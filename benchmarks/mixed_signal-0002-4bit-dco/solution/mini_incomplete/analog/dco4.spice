.subckt dco4 EN CTRL0 CTRL1 CTRL2 CTRL3 OUT VDD VSS
Rbad OUT VSS 1
.ends dco4
