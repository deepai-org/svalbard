* SPDX-License-Identifier: Apache-2.0
* Nominal functional smoke test; not performance evidence.
.include /foss/pdks/gf180mcuD/libs.tech/ngspice/design.ngspice
.lib /foss/pdks/gf180mcuD/libs.tech/ngspice/sm141064.ngspice typical
.include /work/inverter_magic.spice

Vvdd VDD 0 5
Vvnw VNW 0 5
Vvpw VPW 0 0
Vin I 0 PULSE(0 5 1n 50p 50p 1n 4n)
Cload ZN 0 5f
Xdut I ZN VDD VNW VPW 0 inverter

.tran 5p 3.5n
.measure tran vout_high_initial FIND v(ZN) AT=0.5n
.measure tran vout_low FIND v(ZN) AT=1.7n
.measure tran vout_high_final FIND v(ZN) AT=3.0n
.measure tran t_phl TRIG v(I) VAL=2.5 RISE=1 TARG v(ZN) VAL=2.5 FALL=1
.measure tran t_plh TRIG v(I) VAL=2.5 FALL=1 TARG v(ZN) VAL=2.5 RISE=1
.end
