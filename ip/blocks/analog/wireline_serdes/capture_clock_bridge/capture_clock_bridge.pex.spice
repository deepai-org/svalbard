* PEX produced using /foss/tools/sak/sak-pex.sh with m=3 and s=1 (extresist threshold=0 mOhm, minres=1 mOhm, mindelay=0 ps)
* NGSPICE file created from capture_clock_bridge_pex.ext - technology: gf180mcuD

.subckt capture_clock_bridge_pex E_WRITE O_WRITE E_CAPTURE_CLK E_CAPTURE_CLKB O_CAPTURE_CLK
+ O_CAPTURE_CLKB VDD VSS
X0 O_CAPTURE_CLK.t17 O_CAPTURE_CLKB.t32 VDD.t79 VDD.t78 pfet_03v3 ad=5.28p pd=24.88u as=3.12p ps=12.52u w=12u l=0.28u
X1 VDD.t54 E_WRITE.t9 E_CAPTURE_CLKB.t8 VDD.t36 pfet_03v3 ad=2.08p pd=8.52u as=2.08p ps=8.52u w=8u l=0.28u
X2 E_CAPTURE_CLK.t30 E_CAPTURE_CLKB.t22 VSS.t35 VSS.t34 nfet_03v3 ad=1.3p pd=5.52u as=1.3p ps=5.52u w=5u l=0.28u
X3 E_CAPTURE_CLKB.t2 E_WRITE.t0 VSS.t55 VSS.t38 nfet_03v3 ad=4.4p pd=20.88u as=2.6p ps=10.52u w=10u l=0.28u
X4 O_CAPTURE_CLKB.t8 O_WRITE.t14 VDD.t3 VDD.t2 pfet_03v3 ad=2.08p pd=8.52u as=2.08p ps=8.52u w=8u l=0.28u
X5 VSS.t37 E_CAPTURE_CLKB.t21 E_CAPTURE_CLK.t7 VSS.t36 nfet_03v3 ad=1.3p pd=5.52u as=1.3p ps=5.52u w=5u l=0.28u
X6 VDD.t41 E_CAPTURE_CLKB.t35 E_CAPTURE_CLK.t1 VDD.t40 pfet_03v3 ad=3.12p pd=12.52u as=3.12p ps=12.52u w=12u l=0.28u
X7 VDD.t64 O_CAPTURE_CLKB.t43 O_CAPTURE_CLK.t9 VDD.t0 pfet_03v3 ad=3.12p pd=12.52u as=3.12p ps=12.52u w=12u l=0.28u
X8 VDD.t1 O_WRITE.t15 O_CAPTURE_CLKB.t15 VDD.t0 pfet_03v3 ad=2.08p pd=8.52u as=3.52p ps=16.88u w=8u l=0.28u
X9 O_CAPTURE_CLK.t24 O_CAPTURE_CLKB.t26 VSS.t65 VSS.t2 nfet_03v3 ad=1.3p pd=5.52u as=1.3p ps=5.52u w=5u l=0.28u
X10 VSS.t48 E_WRITE.t7 E_CAPTURE_CLKB.t6 VSS.t24 nfet_03v3 ad=2.6p pd=10.52u as=4.4p ps=20.88u w=10u l=0.28u
X11 E_CAPTURE_CLK.t12 E_CAPTURE_CLKB.t28 VSS.t23 VSS.t22 nfet_03v3 ad=1.3p pd=5.52u as=1.3p ps=5.52u w=5u l=0.28u
X12 VSS.t64 O_CAPTURE_CLKB.t27 O_CAPTURE_CLK.t16 VSS.t0 nfet_03v3 ad=1.3p pd=5.52u as=1.3p ps=5.52u w=5u l=0.28u
X13 E_CAPTURE_CLKB.t10 E_WRITE.t4 VSS.t51 VSS.t30 nfet_03v3 ad=2.6p pd=10.52u as=2.6p ps=10.52u w=10u l=0.28u
X14 O_CAPTURE_CLKB.t5 O_WRITE.t8 VDD.t15 VDD.t14 pfet_03v3 ad=3.52p pd=16.88u as=2.08p ps=8.52u w=8u l=0.28u
X15 VSS.t73 O_CAPTURE_CLKB.t19 O_CAPTURE_CLK.t14 VSS.t72 nfet_03v3 ad=1.3p pd=5.52u as=1.3p ps=5.52u w=5u l=0.28u
X16 E_CAPTURE_CLKB.t9 E_WRITE.t6 VSS.t49 VSS.t26 nfet_03v3 ad=2.6p pd=10.52u as=2.6p ps=10.52u w=10u l=0.28u
X17 VSS.t9 O_WRITE.t3 O_CAPTURE_CLKB.t0 VSS.t8 nfet_03v3 ad=2.6p pd=10.52u as=2.6p ps=10.52u w=10u l=0.28u
X18 E_CAPTURE_CLK.t25 E_CAPTURE_CLKB.t32 VDD.t47 VDD.t46 pfet_03v3 ad=5.28p pd=24.88u as=3.12p ps=12.52u w=12u l=0.28u
X19 O_CAPTURE_CLK.t30 O_CAPTURE_CLKB.t46 VDD.t59 VDD.t58 pfet_03v3 ad=3.12p pd=12.52u as=3.12p ps=12.52u w=12u l=0.28u
X20 O_CAPTURE_CLK.t6 O_CAPTURE_CLKB.t20 VSS.t71 VSS.t14 nfet_03v3 ad=1.3p pd=5.52u as=1.3p ps=5.52u w=5u l=0.28u
X21 VSS.t13 O_WRITE.t1 O_CAPTURE_CLKB.t1 VSS.t12 nfet_03v3 ad=2.6p pd=10.52u as=2.6p ps=10.52u w=10u l=0.28u
X22 O_CAPTURE_CLKB.t10 O_WRITE.t2 VSS.t11 VSS.t10 nfet_03v3 ad=2.6p pd=10.52u as=2.6p ps=10.52u w=10u l=0.28u
X23 O_CAPTURE_CLK.t25 O_CAPTURE_CLKB.t38 VDD.t69 VDD.t10 pfet_03v3 ad=3.12p pd=12.52u as=3.12p ps=12.52u w=12u l=0.28u
X24 O_CAPTURE_CLK.t22 O_CAPTURE_CLKB.t44 VDD.t63 VDD.t62 pfet_03v3 ad=3.12p pd=12.52u as=3.12p ps=12.52u w=12u l=0.28u
X25 E_CAPTURE_CLKB.t11 E_WRITE.t8 VDD.t55 VDD.t38 pfet_03v3 ad=3.52p pd=16.88u as=2.08p ps=8.52u w=8u l=0.28u
X26 VDD.t37 E_CAPTURE_CLKB.t37 E_CAPTURE_CLK.t24 VDD.t36 pfet_03v3 ad=3.12p pd=12.52u as=3.12p ps=12.52u w=12u l=0.28u
X27 VDD.t66 O_CAPTURE_CLKB.t41 O_CAPTURE_CLK.t1 VDD.t4 pfet_03v3 ad=3.12p pd=12.52u as=3.12p ps=12.52u w=12u l=0.28u
X28 E_CAPTURE_CLK.t8 E_CAPTURE_CLKB.t20 VSS.t39 VSS.t38 nfet_03v3 ad=1.3p pd=5.52u as=1.3p ps=5.52u w=5u l=0.28u
X29 E_CAPTURE_CLK.t9 E_CAPTURE_CLKB.t18 VSS.t43 VSS.t42 nfet_03v3 ad=1.3p pd=5.52u as=1.3p ps=5.52u w=5u l=0.28u
X30 E_CAPTURE_CLK.t21 E_CAPTURE_CLKB.t40 VDD.t31 VDD.t30 pfet_03v3 ad=3.12p pd=12.52u as=3.12p ps=12.52u w=12u l=0.28u
X31 VDD.t48 E_WRITE.t15 E_CAPTURE_CLKB.t14 VDD.t24 pfet_03v3 ad=2.08p pd=8.52u as=3.52p ps=16.88u w=8u l=0.28u
X32 VSS.t41 E_CAPTURE_CLKB.t19 E_CAPTURE_CLK.t2 VSS.t40 nfet_03v3 ad=1.3p pd=5.52u as=1.3p ps=5.52u w=5u l=0.28u
X33 VSS.t61 O_CAPTURE_CLKB.t29 O_CAPTURE_CLK.t28 VSS.t60 nfet_03v3 ad=1.3p pd=5.52u as=1.3p ps=5.52u w=5u l=0.28u
X34 VDD.t57 O_CAPTURE_CLKB.t47 O_CAPTURE_CLK.t31 VDD.t56 pfet_03v3 ad=3.12p pd=12.52u as=5.28p ps=24.88u w=12u l=0.28u
X35 E_CAPTURE_CLKB.t13 E_WRITE.t14 VDD.t49 VDD.t26 pfet_03v3 ad=2.08p pd=8.52u as=2.08p ps=8.52u w=8u l=0.28u
X36 E_CAPTURE_CLKB.t12 E_WRITE.t12 VDD.t51 VDD.t30 pfet_03v3 ad=2.08p pd=8.52u as=2.08p ps=8.52u w=8u l=0.28u
X37 VSS.t25 E_CAPTURE_CLKB.t27 E_CAPTURE_CLK.t6 VSS.t24 nfet_03v3 ad=1.3p pd=5.52u as=1.3p ps=5.52u w=5u l=0.28u
X38 O_CAPTURE_CLK.t20 O_CAPTURE_CLKB.t30 VSS.t59 VSS.t58 nfet_03v3 ad=1.3p pd=5.52u as=1.3p ps=5.52u w=5u l=0.28u
X39 O_CAPTURE_CLK.t27 O_CAPTURE_CLKB.t28 VSS.t63 VSS.t62 nfet_03v3 ad=1.3p pd=5.52u as=1.3p ps=5.52u w=5u l=0.28u
X40 VSS.t52 E_WRITE.t3 E_CAPTURE_CLKB.t4 VSS.t32 nfet_03v3 ad=2.6p pd=10.52u as=2.6p ps=10.52u w=10u l=0.28u
X41 E_CAPTURE_CLK.t0 E_CAPTURE_CLKB.t34 VDD.t43 VDD.t42 pfet_03v3 ad=3.12p pd=12.52u as=3.12p ps=12.52u w=12u l=0.28u
X42 VDD.t9 O_WRITE.t11 O_CAPTURE_CLKB.t7 VDD.t8 pfet_03v3 ad=2.08p pd=8.52u as=2.08p ps=8.52u w=8u l=0.28u
X43 VDD.t13 O_WRITE.t9 O_CAPTURE_CLKB.t11 VDD.t12 pfet_03v3 ad=2.08p pd=8.52u as=2.08p ps=8.52u w=8u l=0.28u
X44 E_CAPTURE_CLK.t5 E_CAPTURE_CLKB.t26 VSS.t27 VSS.t26 nfet_03v3 ad=1.3p pd=5.52u as=1.3p ps=5.52u w=5u l=0.28u
X45 E_CAPTURE_CLK.t19 E_CAPTURE_CLKB.t24 VSS.t31 VSS.t30 nfet_03v3 ad=1.3p pd=5.52u as=1.3p ps=5.52u w=5u l=0.28u
X46 VSS.t50 E_WRITE.t5 E_CAPTURE_CLKB.t7 VSS.t28 nfet_03v3 ad=2.6p pd=10.52u as=2.6p ps=10.52u w=10u l=0.28u
X47 O_CAPTURE_CLKB.t6 O_WRITE.t10 VDD.t11 VDD.t10 pfet_03v3 ad=2.08p pd=8.52u as=2.08p ps=8.52u w=8u l=0.28u
X48 VSS.t68 O_CAPTURE_CLKB.t23 O_CAPTURE_CLK.t2 VSS.t8 nfet_03v3 ad=1.3p pd=5.52u as=1.3p ps=5.52u w=5u l=0.28u
X49 O_CAPTURE_CLKB.t9 O_WRITE.t4 VSS.t7 VSS.t6 nfet_03v3 ad=2.6p pd=10.52u as=2.6p ps=10.52u w=10u l=0.28u
X50 E_CAPTURE_CLK.t3 E_CAPTURE_CLKB.t42 VDD.t27 VDD.t26 pfet_03v3 ad=3.12p pd=12.52u as=3.12p ps=12.52u w=12u l=0.28u
X51 O_CAPTURE_CLK.t4 O_CAPTURE_CLKB.t36 VDD.t71 VDD.t14 pfet_03v3 ad=3.12p pd=12.52u as=3.12p ps=12.52u w=12u l=0.28u
X52 VSS.t70 O_CAPTURE_CLKB.t21 O_CAPTURE_CLK.t19 VSS.t12 nfet_03v3 ad=1.3p pd=5.52u as=1.3p ps=5.52u w=5u l=0.28u
X53 VSS.t5 O_WRITE.t5 O_CAPTURE_CLKB.t4 VSS.t4 nfet_03v3 ad=2.6p pd=10.52u as=2.6p ps=10.52u w=10u l=0.28u
X54 VDD.t21 E_CAPTURE_CLKB.t45 E_CAPTURE_CLK.t11 VDD.t20 pfet_03v3 ad=3.12p pd=12.52u as=3.12p ps=12.52u w=12u l=0.28u
X55 VDD.t77 O_CAPTURE_CLKB.t33 O_CAPTURE_CLK.t18 VDD.t76 pfet_03v3 ad=3.12p pd=12.52u as=3.12p ps=12.52u w=12u l=0.28u
X56 O_CAPTURE_CLK.t7 O_CAPTURE_CLKB.t22 VSS.t69 VSS.t10 nfet_03v3 ad=1.3p pd=5.52u as=1.3p ps=5.52u w=5u l=0.28u
X57 O_CAPTURE_CLK.t15 O_CAPTURE_CLKB.t16 VSS.t79 VSS.t78 nfet_03v3 ad=2.2p pd=10.88u as=1.3p ps=5.52u w=5u l=0.28u
X58 E_CAPTURE_CLK.t23 E_CAPTURE_CLKB.t36 VDD.t39 VDD.t38 pfet_03v3 ad=3.12p pd=12.52u as=3.12p ps=12.52u w=12u l=0.28u
X59 O_CAPTURE_CLK.t8 O_CAPTURE_CLKB.t42 VDD.t65 VDD.t2 pfet_03v3 ad=3.12p pd=12.52u as=3.12p ps=12.52u w=12u l=0.28u
X60 VDD.t33 E_CAPTURE_CLKB.t39 E_CAPTURE_CLK.t29 VDD.t32 pfet_03v3 ad=3.12p pd=12.52u as=3.12p ps=12.52u w=12u l=0.28u
X61 VDD.t68 O_CAPTURE_CLKB.t39 O_CAPTURE_CLK.t26 VDD.t8 pfet_03v3 ad=3.12p pd=12.52u as=3.12p ps=12.52u w=12u l=0.28u
X62 VSS.t77 O_CAPTURE_CLKB.t17 O_CAPTURE_CLK.t10 VSS.t76 nfet_03v3 ad=1.3p pd=5.52u as=1.3p ps=5.52u w=5u l=0.28u
X63 VDD.t45 E_CAPTURE_CLKB.t33 E_CAPTURE_CLK.t26 VDD.t44 pfet_03v3 ad=3.12p pd=12.52u as=3.12p ps=12.52u w=12u l=0.28u
X64 VDD.t61 O_CAPTURE_CLKB.t45 O_CAPTURE_CLK.t23 VDD.t60 pfet_03v3 ad=3.12p pd=12.52u as=3.12p ps=12.52u w=12u l=0.28u
X65 VSS.t45 E_CAPTURE_CLKB.t17 E_CAPTURE_CLK.t27 VSS.t44 nfet_03v3 ad=1.3p pd=5.52u as=1.3p ps=5.52u w=5u l=0.28u
X66 VDD.t17 E_CAPTURE_CLKB.t47 E_CAPTURE_CLK.t15 VDD.t16 pfet_03v3 ad=3.12p pd=12.52u as=5.28p ps=24.88u w=12u l=0.28u
X67 E_CAPTURE_CLK.t18 E_CAPTURE_CLKB.t16 VSS.t47 VSS.t46 nfet_03v3 ad=2.2p pd=10.88u as=1.3p ps=5.52u w=5u l=0.28u
X68 VDD.t50 E_WRITE.t13 E_CAPTURE_CLKB.t15 VDD.t28 pfet_03v3 ad=2.08p pd=8.52u as=2.08p ps=8.52u w=8u l=0.28u
X69 VDD.t52 E_WRITE.t11 E_CAPTURE_CLKB.t3 VDD.t32 pfet_03v3 ad=2.08p pd=8.52u as=2.08p ps=8.52u w=8u l=0.28u
X70 VSS.t57 O_CAPTURE_CLKB.t31 O_CAPTURE_CLK.t21 VSS.t56 nfet_03v3 ad=1.3p pd=5.52u as=2.2p ps=10.88u w=5u l=0.28u
X71 VDD.t29 E_CAPTURE_CLKB.t41 E_CAPTURE_CLK.t22 VDD.t28 pfet_03v3 ad=3.12p pd=12.52u as=3.12p ps=12.52u w=12u l=0.28u
X72 VDD.t70 O_CAPTURE_CLKB.t37 O_CAPTURE_CLK.t5 VDD.t12 pfet_03v3 ad=3.12p pd=12.52u as=3.12p ps=12.52u w=12u l=0.28u
X73 O_CAPTURE_CLKB.t2 O_WRITE.t12 VDD.t7 VDD.t6 pfet_03v3 ad=2.08p pd=8.52u as=2.08p ps=8.52u w=8u l=0.28u
X74 VSS.t33 E_CAPTURE_CLKB.t23 E_CAPTURE_CLK.t31 VSS.t32 nfet_03v3 ad=1.3p pd=5.52u as=1.3p ps=5.52u w=5u l=0.28u
X75 E_CAPTURE_CLKB.t5 E_WRITE.t2 VSS.t53 VSS.t34 nfet_03v3 ad=2.6p pd=10.52u as=2.6p ps=10.52u w=10u l=0.28u
X76 E_CAPTURE_CLK.t10 E_CAPTURE_CLKB.t44 VDD.t23 VDD.t22 pfet_03v3 ad=3.12p pd=12.52u as=3.12p ps=12.52u w=12u l=0.28u
X77 O_CAPTURE_CLK.t12 O_CAPTURE_CLKB.t34 VDD.t75 VDD.t74 pfet_03v3 ad=3.12p pd=12.52u as=3.12p ps=12.52u w=12u l=0.28u
X78 VDD.t5 O_WRITE.t13 O_CAPTURE_CLKB.t12 VDD.t4 pfet_03v3 ad=2.08p pd=8.52u as=2.08p ps=8.52u w=8u l=0.28u
X79 VSS.t29 E_CAPTURE_CLKB.t25 E_CAPTURE_CLK.t20 VSS.t28 nfet_03v3 ad=1.3p pd=5.52u as=1.3p ps=5.52u w=5u l=0.28u
X80 O_CAPTURE_CLK.t11 O_CAPTURE_CLKB.t24 VSS.t67 VSS.t6 nfet_03v3 ad=1.3p pd=5.52u as=1.3p ps=5.52u w=5u l=0.28u
X81 VSS.t54 E_WRITE.t1 E_CAPTURE_CLKB.t1 VSS.t36 nfet_03v3 ad=2.6p pd=10.52u as=2.6p ps=10.52u w=10u l=0.28u
X82 E_CAPTURE_CLK.t28 E_CAPTURE_CLKB.t38 VDD.t35 VDD.t34 pfet_03v3 ad=3.12p pd=12.52u as=3.12p ps=12.52u w=12u l=0.28u
X83 E_CAPTURE_CLK.t16 E_CAPTURE_CLKB.t30 VSS.t19 VSS.t18 nfet_03v3 ad=1.3p pd=5.52u as=1.3p ps=5.52u w=5u l=0.28u
X84 O_CAPTURE_CLKB.t13 O_WRITE.t6 VSS.t3 VSS.t2 nfet_03v3 ad=2.6p pd=10.52u as=2.6p ps=10.52u w=10u l=0.28u
X85 O_CAPTURE_CLK.t0 O_CAPTURE_CLKB.t40 VDD.t67 VDD.t6 pfet_03v3 ad=3.12p pd=12.52u as=3.12p ps=12.52u w=12u l=0.28u
X86 VSS.t66 O_CAPTURE_CLKB.t25 O_CAPTURE_CLK.t3 VSS.t4 nfet_03v3 ad=1.3p pd=5.52u as=1.3p ps=5.52u w=5u l=0.28u
X87 VSS.t1 O_WRITE.t7 O_CAPTURE_CLKB.t14 VSS.t0 nfet_03v3 ad=2.6p pd=10.52u as=4.4p ps=20.88u w=10u l=0.28u
X88 VSS.t17 E_CAPTURE_CLKB.t31 E_CAPTURE_CLK.t17 VSS.t16 nfet_03v3 ad=1.3p pd=5.52u as=2.2p ps=10.88u w=5u l=0.28u
X89 VSS.t21 E_CAPTURE_CLKB.t29 E_CAPTURE_CLK.t13 VSS.t20 nfet_03v3 ad=1.3p pd=5.52u as=1.3p ps=5.52u w=5u l=0.28u
X90 O_CAPTURE_CLK.t29 O_CAPTURE_CLKB.t18 VSS.t75 VSS.t74 nfet_03v3 ad=1.3p pd=5.52u as=1.3p ps=5.52u w=5u l=0.28u
X91 O_CAPTURE_CLKB.t3 O_WRITE.t0 VSS.t15 VSS.t14 nfet_03v3 ad=4.4p pd=20.88u as=2.6p ps=10.52u w=10u l=0.28u
X92 VDD.t25 E_CAPTURE_CLKB.t43 E_CAPTURE_CLK.t4 VDD.t24 pfet_03v3 ad=3.12p pd=12.52u as=3.12p ps=12.52u w=12u l=0.28u
X93 E_CAPTURE_CLK.t14 E_CAPTURE_CLKB.t46 VDD.t19 VDD.t18 pfet_03v3 ad=3.12p pd=12.52u as=3.12p ps=12.52u w=12u l=0.28u
X94 VDD.t73 O_CAPTURE_CLKB.t35 O_CAPTURE_CLK.t13 VDD.t72 pfet_03v3 ad=3.12p pd=12.52u as=3.12p ps=12.52u w=12u l=0.28u
X95 E_CAPTURE_CLKB.t0 E_WRITE.t10 VDD.t53 VDD.t34 pfet_03v3 ad=2.08p pd=8.52u as=2.08p ps=8.52u w=8u l=0.28u
R0 O_WRITE.n15 O_WRITE.t7 139.702
R1 O_WRITE.n19 O_WRITE.t0 139.702
R2 O_WRITE.n21 O_WRITE.t2 135.246
R3 O_WRITE.n22 O_WRITE.t3 135.246
R4 O_WRITE.n23 O_WRITE.t4 135.246
R5 O_WRITE.n17 O_WRITE.t5 135.246
R6 O_WRITE.n16 O_WRITE.t6 135.246
R7 O_WRITE.n18 O_WRITE.t1 135.246
R8 O_WRITE.n6 O_WRITE.t8 113.632
R9 O_WRITE.n2 O_WRITE.t15 113.632
R10 O_WRITE.n7 O_WRITE.t9 109.174
R11 O_WRITE.n8 O_WRITE.t10 109.174
R12 O_WRITE.n9 O_WRITE.t11 109.174
R13 O_WRITE.n10 O_WRITE.t12 109.174
R14 O_WRITE.n4 O_WRITE.t13 109.174
R15 O_WRITE.n3 O_WRITE.t14 109.174
R16 O_WRITE.n21 O_WRITE.n20 18.4942
R17 O_WRITE.n22 O_WRITE.n13 18.4942
R18 O_WRITE.n24 O_WRITE.n23 18.4942
R19 O_WRITE.n17 O_WRITE.n14 18.4942
R20 O_WRITE.n8 O_WRITE.n5 18.4942
R21 O_WRITE.n9 O_WRITE.n0 18.4942
R22 O_WRITE.n11 O_WRITE.n10 18.4942
R23 O_WRITE.n4 O_WRITE.n1 18.4942
R24 O_WRITE.n26 O_WRITE.n12 16.8853
R25 O_WRITE O_WRITE.n26 12.0793
R26 O_WRITE.n21 O_WRITE.n18 11.6805
R27 O_WRITE.n22 O_WRITE.n21 11.6805
R28 O_WRITE.n23 O_WRITE.n22 11.6805
R29 O_WRITE.n23 O_WRITE.n17 11.6805
R30 O_WRITE.n17 O_WRITE.n16 11.6805
R31 O_WRITE.n8 O_WRITE.n7 11.6805
R32 O_WRITE.n9 O_WRITE.n8 11.6805
R33 O_WRITE.n10 O_WRITE.n9 11.6805
R34 O_WRITE.n10 O_WRITE.n4 11.6805
R35 O_WRITE.n4 O_WRITE.n3 11.6805
R36 O_WRITE.n26 O_WRITE.n25 10.1157
R37 O_WRITE.n20 O_WRITE.n19 7.17687
R38 O_WRITE.n15 O_WRITE.n14 7.17687
R39 O_WRITE.n6 O_WRITE.n5 7.17687
R40 O_WRITE.n2 O_WRITE.n1 7.17687
R41 O_WRITE.n16 O_WRITE.n15 4.42851
R42 O_WRITE.n19 O_WRITE.n18 4.42851
R43 O_WRITE.n7 O_WRITE.n6 4.42851
R44 O_WRITE.n3 O_WRITE.n2 4.42851
R45 O_WRITE.n20 O_WRITE.n13 0.118
R46 O_WRITE.n24 O_WRITE.n14 0.118
R47 O_WRITE.n5 O_WRITE.n0 0.118
R48 O_WRITE.n11 O_WRITE.n1 0.118
R49 O_WRITE.n25 O_WRITE.n24 0.0405
R50 O_WRITE.n25 O_WRITE.n13 0.0405
R51 O_WRITE.n12 O_WRITE.n11 0.0405
R52 O_WRITE.n12 O_WRITE.n0 0.0405
R53 E_WRITE.n15 E_WRITE.t7 139.702
R54 E_WRITE.n19 E_WRITE.t0 139.702
R55 E_WRITE.n21 E_WRITE.t2 135.246
R56 E_WRITE.n22 E_WRITE.t3 135.246
R57 E_WRITE.n23 E_WRITE.t4 135.246
R58 E_WRITE.n17 E_WRITE.t5 135.246
R59 E_WRITE.n16 E_WRITE.t6 135.246
R60 E_WRITE.n18 E_WRITE.t1 135.246
R61 E_WRITE.n6 E_WRITE.t8 113.632
R62 E_WRITE.n2 E_WRITE.t15 113.632
R63 E_WRITE.n7 E_WRITE.t9 109.174
R64 E_WRITE.n8 E_WRITE.t10 109.174
R65 E_WRITE.n9 E_WRITE.t11 109.174
R66 E_WRITE.n10 E_WRITE.t12 109.174
R67 E_WRITE.n4 E_WRITE.t13 109.174
R68 E_WRITE.n3 E_WRITE.t14 109.174
R69 E_WRITE.n21 E_WRITE.n20 18.4942
R70 E_WRITE.n22 E_WRITE.n13 18.4942
R71 E_WRITE.n24 E_WRITE.n23 18.4942
R72 E_WRITE.n17 E_WRITE.n14 18.4942
R73 E_WRITE.n8 E_WRITE.n5 18.4942
R74 E_WRITE.n9 E_WRITE.n0 18.4942
R75 E_WRITE.n11 E_WRITE.n10 18.4942
R76 E_WRITE.n4 E_WRITE.n1 18.4942
R77 E_WRITE.n26 E_WRITE.n12 18.0005
R78 E_WRITE E_WRITE.n26 12.3337
R79 E_WRITE.n21 E_WRITE.n18 11.6805
R80 E_WRITE.n22 E_WRITE.n21 11.6805
R81 E_WRITE.n23 E_WRITE.n22 11.6805
R82 E_WRITE.n23 E_WRITE.n17 11.6805
R83 E_WRITE.n17 E_WRITE.n16 11.6805
R84 E_WRITE.n8 E_WRITE.n7 11.6805
R85 E_WRITE.n9 E_WRITE.n8 11.6805
R86 E_WRITE.n10 E_WRITE.n9 11.6805
R87 E_WRITE.n10 E_WRITE.n4 11.6805
R88 E_WRITE.n4 E_WRITE.n3 11.6805
R89 E_WRITE.n26 E_WRITE.n25 9.0005
R90 E_WRITE.n20 E_WRITE.n19 7.17687
R91 E_WRITE.n15 E_WRITE.n14 7.17687
R92 E_WRITE.n6 E_WRITE.n5 7.17687
R93 E_WRITE.n2 E_WRITE.n1 7.17687
R94 E_WRITE.n16 E_WRITE.n15 4.42851
R95 E_WRITE.n19 E_WRITE.n18 4.42851
R96 E_WRITE.n7 E_WRITE.n6 4.42851
R97 E_WRITE.n3 E_WRITE.n2 4.42851
R98 E_WRITE.n20 E_WRITE.n13 0.118
R99 E_WRITE.n24 E_WRITE.n14 0.118
R100 E_WRITE.n5 E_WRITE.n0 0.118
R101 E_WRITE.n11 E_WRITE.n1 0.118
R102 E_WRITE.n25 E_WRITE.n24 0.0405
R103 E_WRITE.n25 E_WRITE.n13 0.0405
R104 E_WRITE.n12 E_WRITE.n11 0.0405
R105 E_WRITE.n12 E_WRITE.n0 0.0405
R106 O_CAPTURE_CLK O_CAPTURE_CLK.n30 11.9372
R107 O_CAPTURE_CLK.n30 O_CAPTURE_CLK.n14 11.1918
R108 O_CAPTURE_CLK.n30 O_CAPTURE_CLK.n29 6.51572
R109 O_CAPTURE_CLK.n16 O_CAPTURE_CLK.t15 5.92079
R110 O_CAPTURE_CLK.n24 O_CAPTURE_CLK.t21 5.92079
R111 O_CAPTURE_CLK.n1 O_CAPTURE_CLK.t17 5.88535
R112 O_CAPTURE_CLK.n9 O_CAPTURE_CLK.t31 5.88535
R113 O_CAPTURE_CLK.n1 O_CAPTURE_CLK.n0 5.54421
R114 O_CAPTURE_CLK.n3 O_CAPTURE_CLK.n2 5.54421
R115 O_CAPTURE_CLK.n5 O_CAPTURE_CLK.n4 5.54421
R116 O_CAPTURE_CLK.n7 O_CAPTURE_CLK.n6 5.54421
R117 O_CAPTURE_CLK.n13 O_CAPTURE_CLK.n12 5.54421
R118 O_CAPTURE_CLK.n11 O_CAPTURE_CLK.n10 5.54421
R119 O_CAPTURE_CLK.n9 O_CAPTURE_CLK.n8 5.54421
R120 O_CAPTURE_CLK.n16 O_CAPTURE_CLK.n15 5.40371
R121 O_CAPTURE_CLK.n18 O_CAPTURE_CLK.n17 5.40371
R122 O_CAPTURE_CLK.n20 O_CAPTURE_CLK.n19 5.40371
R123 O_CAPTURE_CLK.n22 O_CAPTURE_CLK.n21 5.40371
R124 O_CAPTURE_CLK.n28 O_CAPTURE_CLK.n27 5.40371
R125 O_CAPTURE_CLK.n26 O_CAPTURE_CLK.n25 5.40371
R126 O_CAPTURE_CLK.n24 O_CAPTURE_CLK.n23 5.40371
R127 O_CAPTURE_CLK.n15 O_CAPTURE_CLK.t29 0.3281
R128 O_CAPTURE_CLK.n15 O_CAPTURE_CLK.t10 0.3281
R129 O_CAPTURE_CLK.n17 O_CAPTURE_CLK.t6 0.3281
R130 O_CAPTURE_CLK.n17 O_CAPTURE_CLK.t14 0.3281
R131 O_CAPTURE_CLK.n19 O_CAPTURE_CLK.t7 0.3281
R132 O_CAPTURE_CLK.n19 O_CAPTURE_CLK.t19 0.3281
R133 O_CAPTURE_CLK.n21 O_CAPTURE_CLK.t11 0.3281
R134 O_CAPTURE_CLK.n21 O_CAPTURE_CLK.t2 0.3281
R135 O_CAPTURE_CLK.n27 O_CAPTURE_CLK.t24 0.3281
R136 O_CAPTURE_CLK.n27 O_CAPTURE_CLK.t3 0.3281
R137 O_CAPTURE_CLK.n25 O_CAPTURE_CLK.t27 0.3281
R138 O_CAPTURE_CLK.n25 O_CAPTURE_CLK.t16 0.3281
R139 O_CAPTURE_CLK.n23 O_CAPTURE_CLK.t20 0.3281
R140 O_CAPTURE_CLK.n23 O_CAPTURE_CLK.t28 0.3281
R141 O_CAPTURE_CLK.n26 O_CAPTURE_CLK.n24 0.189974
R142 O_CAPTURE_CLK.n28 O_CAPTURE_CLK.n26 0.189974
R143 O_CAPTURE_CLK.n22 O_CAPTURE_CLK.n20 0.189974
R144 O_CAPTURE_CLK.n20 O_CAPTURE_CLK.n18 0.189974
R145 O_CAPTURE_CLK.n18 O_CAPTURE_CLK.n16 0.189974
R146 O_CAPTURE_CLK.n11 O_CAPTURE_CLK.n9 0.189974
R147 O_CAPTURE_CLK.n13 O_CAPTURE_CLK.n11 0.189974
R148 O_CAPTURE_CLK.n7 O_CAPTURE_CLK.n5 0.189974
R149 O_CAPTURE_CLK.n5 O_CAPTURE_CLK.n3 0.189974
R150 O_CAPTURE_CLK.n3 O_CAPTURE_CLK.n1 0.189974
R151 O_CAPTURE_CLK.n0 O_CAPTURE_CLK.t12 0.152167
R152 O_CAPTURE_CLK.n0 O_CAPTURE_CLK.t18 0.152167
R153 O_CAPTURE_CLK.n2 O_CAPTURE_CLK.t4 0.152167
R154 O_CAPTURE_CLK.n2 O_CAPTURE_CLK.t13 0.152167
R155 O_CAPTURE_CLK.n4 O_CAPTURE_CLK.t25 0.152167
R156 O_CAPTURE_CLK.n4 O_CAPTURE_CLK.t5 0.152167
R157 O_CAPTURE_CLK.n6 O_CAPTURE_CLK.t0 0.152167
R158 O_CAPTURE_CLK.n6 O_CAPTURE_CLK.t26 0.152167
R159 O_CAPTURE_CLK.n12 O_CAPTURE_CLK.t8 0.152167
R160 O_CAPTURE_CLK.n12 O_CAPTURE_CLK.t1 0.152167
R161 O_CAPTURE_CLK.n10 O_CAPTURE_CLK.t22 0.152167
R162 O_CAPTURE_CLK.n10 O_CAPTURE_CLK.t9 0.152167
R163 O_CAPTURE_CLK.n8 O_CAPTURE_CLK.t30 0.152167
R164 O_CAPTURE_CLK.n8 O_CAPTURE_CLK.t23 0.152167
R165 O_CAPTURE_CLK.n29 O_CAPTURE_CLK.n28 0.0952368
R166 O_CAPTURE_CLK.n29 O_CAPTURE_CLK.n22 0.0952368
R167 O_CAPTURE_CLK.n14 O_CAPTURE_CLK.n13 0.0952368
R168 O_CAPTURE_CLK.n14 O_CAPTURE_CLK.n7 0.0952368
R169 E_CAPTURE_CLK.n30 E_CAPTURE_CLK.n14 12.757
R170 E_CAPTURE_CLK E_CAPTURE_CLK.n30 11.7477
R171 E_CAPTURE_CLK.n16 E_CAPTURE_CLK.t18 5.92079
R172 E_CAPTURE_CLK.n24 E_CAPTURE_CLK.t17 5.92079
R173 E_CAPTURE_CLK.n1 E_CAPTURE_CLK.t25 5.88535
R174 E_CAPTURE_CLK.n9 E_CAPTURE_CLK.t15 5.88535
R175 E_CAPTURE_CLK.n1 E_CAPTURE_CLK.n0 5.54421
R176 E_CAPTURE_CLK.n3 E_CAPTURE_CLK.n2 5.54421
R177 E_CAPTURE_CLK.n5 E_CAPTURE_CLK.n4 5.54421
R178 E_CAPTURE_CLK.n7 E_CAPTURE_CLK.n6 5.54421
R179 E_CAPTURE_CLK.n13 E_CAPTURE_CLK.n12 5.54421
R180 E_CAPTURE_CLK.n11 E_CAPTURE_CLK.n10 5.54421
R181 E_CAPTURE_CLK.n9 E_CAPTURE_CLK.n8 5.54421
R182 E_CAPTURE_CLK.n16 E_CAPTURE_CLK.n15 5.40371
R183 E_CAPTURE_CLK.n18 E_CAPTURE_CLK.n17 5.40371
R184 E_CAPTURE_CLK.n20 E_CAPTURE_CLK.n19 5.40371
R185 E_CAPTURE_CLK.n22 E_CAPTURE_CLK.n21 5.40371
R186 E_CAPTURE_CLK.n28 E_CAPTURE_CLK.n27 5.40371
R187 E_CAPTURE_CLK.n26 E_CAPTURE_CLK.n25 5.40371
R188 E_CAPTURE_CLK.n24 E_CAPTURE_CLK.n23 5.40371
R189 E_CAPTURE_CLK.n30 E_CAPTURE_CLK.n29 4.9505
R190 E_CAPTURE_CLK.n15 E_CAPTURE_CLK.t9 0.3281
R191 E_CAPTURE_CLK.n15 E_CAPTURE_CLK.t27 0.3281
R192 E_CAPTURE_CLK.n17 E_CAPTURE_CLK.t8 0.3281
R193 E_CAPTURE_CLK.n17 E_CAPTURE_CLK.t2 0.3281
R194 E_CAPTURE_CLK.n19 E_CAPTURE_CLK.t30 0.3281
R195 E_CAPTURE_CLK.n19 E_CAPTURE_CLK.t7 0.3281
R196 E_CAPTURE_CLK.n21 E_CAPTURE_CLK.t19 0.3281
R197 E_CAPTURE_CLK.n21 E_CAPTURE_CLK.t31 0.3281
R198 E_CAPTURE_CLK.n27 E_CAPTURE_CLK.t5 0.3281
R199 E_CAPTURE_CLK.n27 E_CAPTURE_CLK.t20 0.3281
R200 E_CAPTURE_CLK.n25 E_CAPTURE_CLK.t12 0.3281
R201 E_CAPTURE_CLK.n25 E_CAPTURE_CLK.t6 0.3281
R202 E_CAPTURE_CLK.n23 E_CAPTURE_CLK.t16 0.3281
R203 E_CAPTURE_CLK.n23 E_CAPTURE_CLK.t13 0.3281
R204 E_CAPTURE_CLK.n26 E_CAPTURE_CLK.n24 0.189974
R205 E_CAPTURE_CLK.n28 E_CAPTURE_CLK.n26 0.189974
R206 E_CAPTURE_CLK.n22 E_CAPTURE_CLK.n20 0.189974
R207 E_CAPTURE_CLK.n20 E_CAPTURE_CLK.n18 0.189974
R208 E_CAPTURE_CLK.n18 E_CAPTURE_CLK.n16 0.189974
R209 E_CAPTURE_CLK.n11 E_CAPTURE_CLK.n9 0.189974
R210 E_CAPTURE_CLK.n13 E_CAPTURE_CLK.n11 0.189974
R211 E_CAPTURE_CLK.n7 E_CAPTURE_CLK.n5 0.189974
R212 E_CAPTURE_CLK.n5 E_CAPTURE_CLK.n3 0.189974
R213 E_CAPTURE_CLK.n3 E_CAPTURE_CLK.n1 0.189974
R214 E_CAPTURE_CLK.n0 E_CAPTURE_CLK.t0 0.152167
R215 E_CAPTURE_CLK.n0 E_CAPTURE_CLK.t26 0.152167
R216 E_CAPTURE_CLK.n2 E_CAPTURE_CLK.t23 0.152167
R217 E_CAPTURE_CLK.n2 E_CAPTURE_CLK.t1 0.152167
R218 E_CAPTURE_CLK.n4 E_CAPTURE_CLK.t28 0.152167
R219 E_CAPTURE_CLK.n4 E_CAPTURE_CLK.t24 0.152167
R220 E_CAPTURE_CLK.n6 E_CAPTURE_CLK.t21 0.152167
R221 E_CAPTURE_CLK.n6 E_CAPTURE_CLK.t29 0.152167
R222 E_CAPTURE_CLK.n12 E_CAPTURE_CLK.t3 0.152167
R223 E_CAPTURE_CLK.n12 E_CAPTURE_CLK.t22 0.152167
R224 E_CAPTURE_CLK.n10 E_CAPTURE_CLK.t10 0.152167
R225 E_CAPTURE_CLK.n10 E_CAPTURE_CLK.t4 0.152167
R226 E_CAPTURE_CLK.n8 E_CAPTURE_CLK.t14 0.152167
R227 E_CAPTURE_CLK.n8 E_CAPTURE_CLK.t11 0.152167
R228 E_CAPTURE_CLK.n29 E_CAPTURE_CLK.n28 0.0952368
R229 E_CAPTURE_CLK.n29 E_CAPTURE_CLK.n22 0.0952368
R230 E_CAPTURE_CLK.n14 E_CAPTURE_CLK.n13 0.0952368
R231 E_CAPTURE_CLK.n14 E_CAPTURE_CLK.n7 0.0952368
R232 O_CAPTURE_CLKB.n16 O_CAPTURE_CLKB.t32 165.774
R233 O_CAPTURE_CLKB.n4 O_CAPTURE_CLKB.t47 165.774
R234 O_CAPTURE_CLKB.n17 O_CAPTURE_CLKB.t33 161.317
R235 O_CAPTURE_CLKB.n18 O_CAPTURE_CLKB.t34 161.317
R236 O_CAPTURE_CLKB.n19 O_CAPTURE_CLKB.t35 161.317
R237 O_CAPTURE_CLKB.n20 O_CAPTURE_CLKB.t36 161.317
R238 O_CAPTURE_CLKB.n21 O_CAPTURE_CLKB.t37 161.317
R239 O_CAPTURE_CLKB.n22 O_CAPTURE_CLKB.t38 161.317
R240 O_CAPTURE_CLKB.n23 O_CAPTURE_CLKB.t39 161.317
R241 O_CAPTURE_CLKB.n24 O_CAPTURE_CLKB.t40 161.317
R242 O_CAPTURE_CLKB.n25 O_CAPTURE_CLKB.t41 161.317
R243 O_CAPTURE_CLKB.n26 O_CAPTURE_CLKB.t42 161.317
R244 O_CAPTURE_CLKB.n8 O_CAPTURE_CLKB.t43 161.317
R245 O_CAPTURE_CLKB.n7 O_CAPTURE_CLKB.t44 161.317
R246 O_CAPTURE_CLKB.n2 O_CAPTURE_CLKB.t45 161.317
R247 O_CAPTURE_CLKB.n3 O_CAPTURE_CLKB.t46 161.317
R248 O_CAPTURE_CLKB.n40 O_CAPTURE_CLKB.t31 74.5242
R249 O_CAPTURE_CLKB.n48 O_CAPTURE_CLKB.t16 74.5242
R250 O_CAPTURE_CLKB.n60 O_CAPTURE_CLKB.t24 70.0675
R251 O_CAPTURE_CLKB.n61 O_CAPTURE_CLKB.t25 70.0675
R252 O_CAPTURE_CLKB.n62 O_CAPTURE_CLKB.t26 70.0675
R253 O_CAPTURE_CLKB.n44 O_CAPTURE_CLKB.t27 70.0675
R254 O_CAPTURE_CLKB.n41 O_CAPTURE_CLKB.t30 70.0675
R255 O_CAPTURE_CLKB.n42 O_CAPTURE_CLKB.t29 70.0675
R256 O_CAPTURE_CLKB.n43 O_CAPTURE_CLKB.t28 70.0675
R257 O_CAPTURE_CLKB.n45 O_CAPTURE_CLKB.t23 70.0675
R258 O_CAPTURE_CLKB.n56 O_CAPTURE_CLKB.t22 70.0675
R259 O_CAPTURE_CLKB.n55 O_CAPTURE_CLKB.t21 70.0675
R260 O_CAPTURE_CLKB.n54 O_CAPTURE_CLKB.t20 70.0675
R261 O_CAPTURE_CLKB.n47 O_CAPTURE_CLKB.t19 70.0675
R262 O_CAPTURE_CLKB.n50 O_CAPTURE_CLKB.t18 70.0675
R263 O_CAPTURE_CLKB.n49 O_CAPTURE_CLKB.t17 70.0675
R264 O_CAPTURE_CLKB.n60 O_CAPTURE_CLKB.n59 18.4942
R265 O_CAPTURE_CLKB.n61 O_CAPTURE_CLKB.n36 18.4942
R266 O_CAPTURE_CLKB.n63 O_CAPTURE_CLKB.n62 18.4942
R267 O_CAPTURE_CLKB.n44 O_CAPTURE_CLKB.n37 18.4942
R268 O_CAPTURE_CLKB.n42 O_CAPTURE_CLKB.n39 18.4942
R269 O_CAPTURE_CLKB.n43 O_CAPTURE_CLKB.n38 18.4942
R270 O_CAPTURE_CLKB.n58 O_CAPTURE_CLKB.n45 18.4942
R271 O_CAPTURE_CLKB.n57 O_CAPTURE_CLKB.n56 18.4942
R272 O_CAPTURE_CLKB.n55 O_CAPTURE_CLKB.n46 18.4942
R273 O_CAPTURE_CLKB.n54 O_CAPTURE_CLKB.n53 18.4942
R274 O_CAPTURE_CLKB.n52 O_CAPTURE_CLKB.n47 18.4942
R275 O_CAPTURE_CLKB.n51 O_CAPTURE_CLKB.n50 18.4942
R276 O_CAPTURE_CLKB.n18 O_CAPTURE_CLKB.n15 18.4942
R277 O_CAPTURE_CLKB.n19 O_CAPTURE_CLKB.n14 18.4942
R278 O_CAPTURE_CLKB.n20 O_CAPTURE_CLKB.n13 18.4942
R279 O_CAPTURE_CLKB.n21 O_CAPTURE_CLKB.n12 18.4942
R280 O_CAPTURE_CLKB.n22 O_CAPTURE_CLKB.n11 18.4942
R281 O_CAPTURE_CLKB.n23 O_CAPTURE_CLKB.n10 18.4942
R282 O_CAPTURE_CLKB.n24 O_CAPTURE_CLKB.n9 18.4942
R283 O_CAPTURE_CLKB.n25 O_CAPTURE_CLKB.n0 18.4942
R284 O_CAPTURE_CLKB.n27 O_CAPTURE_CLKB.n26 18.4942
R285 O_CAPTURE_CLKB.n8 O_CAPTURE_CLKB.n1 18.4942
R286 O_CAPTURE_CLKB.n7 O_CAPTURE_CLKB.n6 18.4942
R287 O_CAPTURE_CLKB.n5 O_CAPTURE_CLKB.n2 18.4942
R288 O_CAPTURE_CLKB O_CAPTURE_CLKB.n72 11.7951
R289 O_CAPTURE_CLKB.n60 O_CAPTURE_CLKB.n45 11.6805
R290 O_CAPTURE_CLKB.n61 O_CAPTURE_CLKB.n60 11.6805
R291 O_CAPTURE_CLKB.n62 O_CAPTURE_CLKB.n61 11.6805
R292 O_CAPTURE_CLKB.n62 O_CAPTURE_CLKB.n44 11.6805
R293 O_CAPTURE_CLKB.n42 O_CAPTURE_CLKB.n41 11.6805
R294 O_CAPTURE_CLKB.n43 O_CAPTURE_CLKB.n42 11.6805
R295 O_CAPTURE_CLKB.n44 O_CAPTURE_CLKB.n43 11.6805
R296 O_CAPTURE_CLKB.n56 O_CAPTURE_CLKB.n45 11.6805
R297 O_CAPTURE_CLKB.n56 O_CAPTURE_CLKB.n55 11.6805
R298 O_CAPTURE_CLKB.n55 O_CAPTURE_CLKB.n54 11.6805
R299 O_CAPTURE_CLKB.n54 O_CAPTURE_CLKB.n47 11.6805
R300 O_CAPTURE_CLKB.n50 O_CAPTURE_CLKB.n47 11.6805
R301 O_CAPTURE_CLKB.n50 O_CAPTURE_CLKB.n49 11.6805
R302 O_CAPTURE_CLKB.n18 O_CAPTURE_CLKB.n17 11.6805
R303 O_CAPTURE_CLKB.n19 O_CAPTURE_CLKB.n18 11.6805
R304 O_CAPTURE_CLKB.n20 O_CAPTURE_CLKB.n19 11.6805
R305 O_CAPTURE_CLKB.n21 O_CAPTURE_CLKB.n20 11.6805
R306 O_CAPTURE_CLKB.n22 O_CAPTURE_CLKB.n21 11.6805
R307 O_CAPTURE_CLKB.n23 O_CAPTURE_CLKB.n22 11.6805
R308 O_CAPTURE_CLKB.n24 O_CAPTURE_CLKB.n23 11.6805
R309 O_CAPTURE_CLKB.n25 O_CAPTURE_CLKB.n24 11.6805
R310 O_CAPTURE_CLKB.n26 O_CAPTURE_CLKB.n25 11.6805
R311 O_CAPTURE_CLKB.n26 O_CAPTURE_CLKB.n8 11.6805
R312 O_CAPTURE_CLKB.n8 O_CAPTURE_CLKB.n7 11.6805
R313 O_CAPTURE_CLKB.n7 O_CAPTURE_CLKB.n2 11.6805
R314 O_CAPTURE_CLKB.n3 O_CAPTURE_CLKB.n2 11.6805
R315 O_CAPTURE_CLKB.n35 O_CAPTURE_CLKB.n28 10.5853
R316 O_CAPTURE_CLKB.n65 O_CAPTURE_CLKB.n64 9.0005
R317 O_CAPTURE_CLKB.n51 O_CAPTURE_CLKB.n48 7.17687
R318 O_CAPTURE_CLKB.n40 O_CAPTURE_CLKB.n39 7.17687
R319 O_CAPTURE_CLKB.n16 O_CAPTURE_CLKB.n15 7.17687
R320 O_CAPTURE_CLKB.n5 O_CAPTURE_CLKB.n4 7.17687
R321 O_CAPTURE_CLKB.n72 O_CAPTURE_CLKB.n71 7.00485
R322 O_CAPTURE_CLKB.n67 O_CAPTURE_CLKB.t3 5.82877
R323 O_CAPTURE_CLKB.n71 O_CAPTURE_CLKB.t14 5.82877
R324 O_CAPTURE_CLKB.n65 O_CAPTURE_CLKB.n35 5.75267
R325 O_CAPTURE_CLKB.n30 O_CAPTURE_CLKB.t5 5.73764
R326 O_CAPTURE_CLKB.n34 O_CAPTURE_CLKB.t15 5.73764
R327 O_CAPTURE_CLKB.n67 O_CAPTURE_CLKB.n66 5.4755
R328 O_CAPTURE_CLKB.n69 O_CAPTURE_CLKB.n68 5.4755
R329 O_CAPTURE_CLKB.n71 O_CAPTURE_CLKB.n70 5.4755
R330 O_CAPTURE_CLKB.n30 O_CAPTURE_CLKB.n29 5.32067
R331 O_CAPTURE_CLKB.n32 O_CAPTURE_CLKB.n31 5.32067
R332 O_CAPTURE_CLKB.n34 O_CAPTURE_CLKB.n33 5.32067
R333 O_CAPTURE_CLKB.n35 O_CAPTURE_CLKB.n34 4.5005
R334 O_CAPTURE_CLKB.n41 O_CAPTURE_CLKB.n40 4.42851
R335 O_CAPTURE_CLKB.n49 O_CAPTURE_CLKB.n48 4.42851
R336 O_CAPTURE_CLKB.n17 O_CAPTURE_CLKB.n16 4.42851
R337 O_CAPTURE_CLKB.n4 O_CAPTURE_CLKB.n3 4.42851
R338 O_CAPTURE_CLKB.n72 O_CAPTURE_CLKB.n65 0.352674
R339 O_CAPTURE_CLKB.n29 O_CAPTURE_CLKB.t6 0.228
R340 O_CAPTURE_CLKB.n29 O_CAPTURE_CLKB.t11 0.228
R341 O_CAPTURE_CLKB.n31 O_CAPTURE_CLKB.t2 0.228
R342 O_CAPTURE_CLKB.n31 O_CAPTURE_CLKB.t7 0.228
R343 O_CAPTURE_CLKB.n33 O_CAPTURE_CLKB.t8 0.228
R344 O_CAPTURE_CLKB.n33 O_CAPTURE_CLKB.t12 0.228
R345 O_CAPTURE_CLKB.n71 O_CAPTURE_CLKB.n69 0.189974
R346 O_CAPTURE_CLKB.n69 O_CAPTURE_CLKB.n67 0.189974
R347 O_CAPTURE_CLKB.n34 O_CAPTURE_CLKB.n32 0.189974
R348 O_CAPTURE_CLKB.n32 O_CAPTURE_CLKB.n30 0.189974
R349 O_CAPTURE_CLKB.n66 O_CAPTURE_CLKB.t10 0.1643
R350 O_CAPTURE_CLKB.n66 O_CAPTURE_CLKB.t1 0.1643
R351 O_CAPTURE_CLKB.n68 O_CAPTURE_CLKB.t9 0.1643
R352 O_CAPTURE_CLKB.n68 O_CAPTURE_CLKB.t0 0.1643
R353 O_CAPTURE_CLKB.n70 O_CAPTURE_CLKB.t13 0.1643
R354 O_CAPTURE_CLKB.n70 O_CAPTURE_CLKB.t4 0.1643
R355 O_CAPTURE_CLKB.n59 O_CAPTURE_CLKB.n58 0.1205
R356 O_CAPTURE_CLKB.n58 O_CAPTURE_CLKB.n57 0.1205
R357 O_CAPTURE_CLKB.n57 O_CAPTURE_CLKB.n46 0.1205
R358 O_CAPTURE_CLKB.n53 O_CAPTURE_CLKB.n46 0.1205
R359 O_CAPTURE_CLKB.n53 O_CAPTURE_CLKB.n52 0.1205
R360 O_CAPTURE_CLKB.n52 O_CAPTURE_CLKB.n51 0.1205
R361 O_CAPTURE_CLKB.n39 O_CAPTURE_CLKB.n38 0.1205
R362 O_CAPTURE_CLKB.n38 O_CAPTURE_CLKB.n37 0.1205
R363 O_CAPTURE_CLKB.n10 O_CAPTURE_CLKB.n9 0.1205
R364 O_CAPTURE_CLKB.n11 O_CAPTURE_CLKB.n10 0.1205
R365 O_CAPTURE_CLKB.n12 O_CAPTURE_CLKB.n11 0.1205
R366 O_CAPTURE_CLKB.n13 O_CAPTURE_CLKB.n12 0.1205
R367 O_CAPTURE_CLKB.n14 O_CAPTURE_CLKB.n13 0.1205
R368 O_CAPTURE_CLKB.n15 O_CAPTURE_CLKB.n14 0.1205
R369 O_CAPTURE_CLKB.n6 O_CAPTURE_CLKB.n5 0.1205
R370 O_CAPTURE_CLKB.n6 O_CAPTURE_CLKB.n1 0.1205
R371 O_CAPTURE_CLKB.n59 O_CAPTURE_CLKB.n36 0.118
R372 O_CAPTURE_CLKB.n63 O_CAPTURE_CLKB.n37 0.118
R373 O_CAPTURE_CLKB.n9 O_CAPTURE_CLKB.n0 0.118
R374 O_CAPTURE_CLKB.n27 O_CAPTURE_CLKB.n1 0.118
R375 O_CAPTURE_CLKB.n64 O_CAPTURE_CLKB.n63 0.0405
R376 O_CAPTURE_CLKB.n64 O_CAPTURE_CLKB.n36 0.0405
R377 O_CAPTURE_CLKB.n28 O_CAPTURE_CLKB.n27 0.0405
R378 O_CAPTURE_CLKB.n28 O_CAPTURE_CLKB.n0 0.0405
R379 E_CAPTURE_CLKB.n16 E_CAPTURE_CLKB.t32 165.774
R380 E_CAPTURE_CLKB.n4 E_CAPTURE_CLKB.t47 165.774
R381 E_CAPTURE_CLKB.n17 E_CAPTURE_CLKB.t33 161.317
R382 E_CAPTURE_CLKB.n18 E_CAPTURE_CLKB.t34 161.317
R383 E_CAPTURE_CLKB.n19 E_CAPTURE_CLKB.t35 161.317
R384 E_CAPTURE_CLKB.n20 E_CAPTURE_CLKB.t36 161.317
R385 E_CAPTURE_CLKB.n21 E_CAPTURE_CLKB.t37 161.317
R386 E_CAPTURE_CLKB.n22 E_CAPTURE_CLKB.t38 161.317
R387 E_CAPTURE_CLKB.n23 E_CAPTURE_CLKB.t39 161.317
R388 E_CAPTURE_CLKB.n24 E_CAPTURE_CLKB.t40 161.317
R389 E_CAPTURE_CLKB.n25 E_CAPTURE_CLKB.t41 161.317
R390 E_CAPTURE_CLKB.n26 E_CAPTURE_CLKB.t42 161.317
R391 E_CAPTURE_CLKB.n8 E_CAPTURE_CLKB.t43 161.317
R392 E_CAPTURE_CLKB.n7 E_CAPTURE_CLKB.t44 161.317
R393 E_CAPTURE_CLKB.n2 E_CAPTURE_CLKB.t45 161.317
R394 E_CAPTURE_CLKB.n3 E_CAPTURE_CLKB.t46 161.317
R395 E_CAPTURE_CLKB.n40 E_CAPTURE_CLKB.t31 74.5242
R396 E_CAPTURE_CLKB.n48 E_CAPTURE_CLKB.t16 74.5242
R397 E_CAPTURE_CLKB.n60 E_CAPTURE_CLKB.t24 70.0675
R398 E_CAPTURE_CLKB.n61 E_CAPTURE_CLKB.t25 70.0675
R399 E_CAPTURE_CLKB.n62 E_CAPTURE_CLKB.t26 70.0675
R400 E_CAPTURE_CLKB.n44 E_CAPTURE_CLKB.t27 70.0675
R401 E_CAPTURE_CLKB.n41 E_CAPTURE_CLKB.t30 70.0675
R402 E_CAPTURE_CLKB.n42 E_CAPTURE_CLKB.t29 70.0675
R403 E_CAPTURE_CLKB.n43 E_CAPTURE_CLKB.t28 70.0675
R404 E_CAPTURE_CLKB.n45 E_CAPTURE_CLKB.t23 70.0675
R405 E_CAPTURE_CLKB.n56 E_CAPTURE_CLKB.t22 70.0675
R406 E_CAPTURE_CLKB.n55 E_CAPTURE_CLKB.t21 70.0675
R407 E_CAPTURE_CLKB.n54 E_CAPTURE_CLKB.t20 70.0675
R408 E_CAPTURE_CLKB.n47 E_CAPTURE_CLKB.t19 70.0675
R409 E_CAPTURE_CLKB.n50 E_CAPTURE_CLKB.t18 70.0675
R410 E_CAPTURE_CLKB.n49 E_CAPTURE_CLKB.t17 70.0675
R411 E_CAPTURE_CLKB.n60 E_CAPTURE_CLKB.n59 18.4942
R412 E_CAPTURE_CLKB.n61 E_CAPTURE_CLKB.n36 18.4942
R413 E_CAPTURE_CLKB.n63 E_CAPTURE_CLKB.n62 18.4942
R414 E_CAPTURE_CLKB.n44 E_CAPTURE_CLKB.n37 18.4942
R415 E_CAPTURE_CLKB.n42 E_CAPTURE_CLKB.n39 18.4942
R416 E_CAPTURE_CLKB.n43 E_CAPTURE_CLKB.n38 18.4942
R417 E_CAPTURE_CLKB.n58 E_CAPTURE_CLKB.n45 18.4942
R418 E_CAPTURE_CLKB.n57 E_CAPTURE_CLKB.n56 18.4942
R419 E_CAPTURE_CLKB.n55 E_CAPTURE_CLKB.n46 18.4942
R420 E_CAPTURE_CLKB.n54 E_CAPTURE_CLKB.n53 18.4942
R421 E_CAPTURE_CLKB.n52 E_CAPTURE_CLKB.n47 18.4942
R422 E_CAPTURE_CLKB.n51 E_CAPTURE_CLKB.n50 18.4942
R423 E_CAPTURE_CLKB.n18 E_CAPTURE_CLKB.n15 18.4942
R424 E_CAPTURE_CLKB.n19 E_CAPTURE_CLKB.n14 18.4942
R425 E_CAPTURE_CLKB.n20 E_CAPTURE_CLKB.n13 18.4942
R426 E_CAPTURE_CLKB.n21 E_CAPTURE_CLKB.n12 18.4942
R427 E_CAPTURE_CLKB.n22 E_CAPTURE_CLKB.n11 18.4942
R428 E_CAPTURE_CLKB.n23 E_CAPTURE_CLKB.n10 18.4942
R429 E_CAPTURE_CLKB.n24 E_CAPTURE_CLKB.n9 18.4942
R430 E_CAPTURE_CLKB.n25 E_CAPTURE_CLKB.n0 18.4942
R431 E_CAPTURE_CLKB.n27 E_CAPTURE_CLKB.n26 18.4942
R432 E_CAPTURE_CLKB.n8 E_CAPTURE_CLKB.n1 18.4942
R433 E_CAPTURE_CLKB.n7 E_CAPTURE_CLKB.n6 18.4942
R434 E_CAPTURE_CLKB.n5 E_CAPTURE_CLKB.n2 18.4942
R435 E_CAPTURE_CLKB.n60 E_CAPTURE_CLKB.n45 11.6805
R436 E_CAPTURE_CLKB.n61 E_CAPTURE_CLKB.n60 11.6805
R437 E_CAPTURE_CLKB.n62 E_CAPTURE_CLKB.n61 11.6805
R438 E_CAPTURE_CLKB.n62 E_CAPTURE_CLKB.n44 11.6805
R439 E_CAPTURE_CLKB.n42 E_CAPTURE_CLKB.n41 11.6805
R440 E_CAPTURE_CLKB.n43 E_CAPTURE_CLKB.n42 11.6805
R441 E_CAPTURE_CLKB.n44 E_CAPTURE_CLKB.n43 11.6805
R442 E_CAPTURE_CLKB.n56 E_CAPTURE_CLKB.n45 11.6805
R443 E_CAPTURE_CLKB.n56 E_CAPTURE_CLKB.n55 11.6805
R444 E_CAPTURE_CLKB.n55 E_CAPTURE_CLKB.n54 11.6805
R445 E_CAPTURE_CLKB.n54 E_CAPTURE_CLKB.n47 11.6805
R446 E_CAPTURE_CLKB.n50 E_CAPTURE_CLKB.n47 11.6805
R447 E_CAPTURE_CLKB.n50 E_CAPTURE_CLKB.n49 11.6805
R448 E_CAPTURE_CLKB.n18 E_CAPTURE_CLKB.n17 11.6805
R449 E_CAPTURE_CLKB.n19 E_CAPTURE_CLKB.n18 11.6805
R450 E_CAPTURE_CLKB.n20 E_CAPTURE_CLKB.n19 11.6805
R451 E_CAPTURE_CLKB.n21 E_CAPTURE_CLKB.n20 11.6805
R452 E_CAPTURE_CLKB.n22 E_CAPTURE_CLKB.n21 11.6805
R453 E_CAPTURE_CLKB.n23 E_CAPTURE_CLKB.n22 11.6805
R454 E_CAPTURE_CLKB.n24 E_CAPTURE_CLKB.n23 11.6805
R455 E_CAPTURE_CLKB.n25 E_CAPTURE_CLKB.n24 11.6805
R456 E_CAPTURE_CLKB.n26 E_CAPTURE_CLKB.n25 11.6805
R457 E_CAPTURE_CLKB.n26 E_CAPTURE_CLKB.n8 11.6805
R458 E_CAPTURE_CLKB.n8 E_CAPTURE_CLKB.n7 11.6805
R459 E_CAPTURE_CLKB.n7 E_CAPTURE_CLKB.n2 11.6805
R460 E_CAPTURE_CLKB.n3 E_CAPTURE_CLKB.n2 11.6805
R461 E_CAPTURE_CLKB E_CAPTURE_CLKB.n72 11.4162
R462 E_CAPTURE_CLKB.n35 E_CAPTURE_CLKB.n28 10.5853
R463 E_CAPTURE_CLKB.n65 E_CAPTURE_CLKB.n64 9.0005
R464 E_CAPTURE_CLKB.n51 E_CAPTURE_CLKB.n48 7.17687
R465 E_CAPTURE_CLKB.n40 E_CAPTURE_CLKB.n39 7.17687
R466 E_CAPTURE_CLKB.n16 E_CAPTURE_CLKB.n15 7.17687
R467 E_CAPTURE_CLKB.n5 E_CAPTURE_CLKB.n4 7.17687
R468 E_CAPTURE_CLKB.n67 E_CAPTURE_CLKB.t2 5.82877
R469 E_CAPTURE_CLKB.n71 E_CAPTURE_CLKB.t6 5.82877
R470 E_CAPTURE_CLKB.n65 E_CAPTURE_CLKB.n35 5.75267
R471 E_CAPTURE_CLKB.n30 E_CAPTURE_CLKB.t11 5.73764
R472 E_CAPTURE_CLKB.n34 E_CAPTURE_CLKB.t14 5.73764
R473 E_CAPTURE_CLKB.n67 E_CAPTURE_CLKB.n66 5.4755
R474 E_CAPTURE_CLKB.n69 E_CAPTURE_CLKB.n68 5.4755
R475 E_CAPTURE_CLKB.n71 E_CAPTURE_CLKB.n70 5.4755
R476 E_CAPTURE_CLKB.n72 E_CAPTURE_CLKB.n71 5.43963
R477 E_CAPTURE_CLKB.n30 E_CAPTURE_CLKB.n29 5.32067
R478 E_CAPTURE_CLKB.n32 E_CAPTURE_CLKB.n31 5.32067
R479 E_CAPTURE_CLKB.n34 E_CAPTURE_CLKB.n33 5.32067
R480 E_CAPTURE_CLKB.n35 E_CAPTURE_CLKB.n34 4.5005
R481 E_CAPTURE_CLKB.n41 E_CAPTURE_CLKB.n40 4.42851
R482 E_CAPTURE_CLKB.n49 E_CAPTURE_CLKB.n48 4.42851
R483 E_CAPTURE_CLKB.n17 E_CAPTURE_CLKB.n16 4.42851
R484 E_CAPTURE_CLKB.n4 E_CAPTURE_CLKB.n3 4.42851
R485 E_CAPTURE_CLKB.n72 E_CAPTURE_CLKB.n65 1.91789
R486 E_CAPTURE_CLKB.n29 E_CAPTURE_CLKB.t0 0.228
R487 E_CAPTURE_CLKB.n29 E_CAPTURE_CLKB.t8 0.228
R488 E_CAPTURE_CLKB.n31 E_CAPTURE_CLKB.t12 0.228
R489 E_CAPTURE_CLKB.n31 E_CAPTURE_CLKB.t3 0.228
R490 E_CAPTURE_CLKB.n33 E_CAPTURE_CLKB.t13 0.228
R491 E_CAPTURE_CLKB.n33 E_CAPTURE_CLKB.t15 0.228
R492 E_CAPTURE_CLKB.n71 E_CAPTURE_CLKB.n69 0.189974
R493 E_CAPTURE_CLKB.n69 E_CAPTURE_CLKB.n67 0.189974
R494 E_CAPTURE_CLKB.n34 E_CAPTURE_CLKB.n32 0.189974
R495 E_CAPTURE_CLKB.n32 E_CAPTURE_CLKB.n30 0.189974
R496 E_CAPTURE_CLKB.n66 E_CAPTURE_CLKB.t5 0.1643
R497 E_CAPTURE_CLKB.n66 E_CAPTURE_CLKB.t1 0.1643
R498 E_CAPTURE_CLKB.n68 E_CAPTURE_CLKB.t10 0.1643
R499 E_CAPTURE_CLKB.n68 E_CAPTURE_CLKB.t4 0.1643
R500 E_CAPTURE_CLKB.n70 E_CAPTURE_CLKB.t9 0.1643
R501 E_CAPTURE_CLKB.n70 E_CAPTURE_CLKB.t7 0.1643
R502 E_CAPTURE_CLKB.n59 E_CAPTURE_CLKB.n58 0.1205
R503 E_CAPTURE_CLKB.n58 E_CAPTURE_CLKB.n57 0.1205
R504 E_CAPTURE_CLKB.n57 E_CAPTURE_CLKB.n46 0.1205
R505 E_CAPTURE_CLKB.n53 E_CAPTURE_CLKB.n46 0.1205
R506 E_CAPTURE_CLKB.n53 E_CAPTURE_CLKB.n52 0.1205
R507 E_CAPTURE_CLKB.n52 E_CAPTURE_CLKB.n51 0.1205
R508 E_CAPTURE_CLKB.n39 E_CAPTURE_CLKB.n38 0.1205
R509 E_CAPTURE_CLKB.n38 E_CAPTURE_CLKB.n37 0.1205
R510 E_CAPTURE_CLKB.n10 E_CAPTURE_CLKB.n9 0.1205
R511 E_CAPTURE_CLKB.n11 E_CAPTURE_CLKB.n10 0.1205
R512 E_CAPTURE_CLKB.n12 E_CAPTURE_CLKB.n11 0.1205
R513 E_CAPTURE_CLKB.n13 E_CAPTURE_CLKB.n12 0.1205
R514 E_CAPTURE_CLKB.n14 E_CAPTURE_CLKB.n13 0.1205
R515 E_CAPTURE_CLKB.n15 E_CAPTURE_CLKB.n14 0.1205
R516 E_CAPTURE_CLKB.n6 E_CAPTURE_CLKB.n5 0.1205
R517 E_CAPTURE_CLKB.n6 E_CAPTURE_CLKB.n1 0.1205
R518 E_CAPTURE_CLKB.n59 E_CAPTURE_CLKB.n36 0.118
R519 E_CAPTURE_CLKB.n63 E_CAPTURE_CLKB.n37 0.118
R520 E_CAPTURE_CLKB.n9 E_CAPTURE_CLKB.n0 0.118
R521 E_CAPTURE_CLKB.n27 E_CAPTURE_CLKB.n1 0.118
R522 E_CAPTURE_CLKB.n64 E_CAPTURE_CLKB.n63 0.0405
R523 E_CAPTURE_CLKB.n64 E_CAPTURE_CLKB.n36 0.0405
R524 E_CAPTURE_CLKB.n28 E_CAPTURE_CLKB.n27 0.0405
R525 E_CAPTURE_CLKB.n28 E_CAPTURE_CLKB.n0 0.0405
R526 VDD.n51 VDD.n46 341.88
R527 VDD.t46 VDD.n46 213.675
R528 VDD.t56 VDD.n51 213.675
R529 VDD.n48 VDD.t16 70.9981
R530 VDD.n53 VDD.t78 70.3399
R531 VDD.n52 VDD.n45 30.6055
R532 VDD.n51 VDD.n50 30.6055
R533 VDD.n49 VDD.n46 30.6055
R534 VDD.n48 VDD.n47 30.6055
R535 VDD.t18 VDD.t16 17.0945
R536 VDD.t20 VDD.t18 17.0945
R537 VDD.t22 VDD.t20 17.0945
R538 VDD.t24 VDD.t22 17.0945
R539 VDD.t26 VDD.t24 17.0945
R540 VDD.t28 VDD.t26 17.0945
R541 VDD.t30 VDD.t28 17.0945
R542 VDD.t32 VDD.t30 17.0945
R543 VDD.t34 VDD.t32 17.0945
R544 VDD.t36 VDD.t34 17.0945
R545 VDD.t38 VDD.t36 17.0945
R546 VDD.t40 VDD.t38 17.0945
R547 VDD.t42 VDD.t44 17.0945
R548 VDD.t44 VDD.t46 17.0945
R549 VDD.t58 VDD.t56 17.0945
R550 VDD.t60 VDD.t58 17.0945
R551 VDD.t0 VDD.t62 17.0945
R552 VDD.t2 VDD.t0 17.0945
R553 VDD.t4 VDD.t2 17.0945
R554 VDD.t6 VDD.t4 17.0945
R555 VDD.t8 VDD.t6 17.0945
R556 VDD.t10 VDD.t8 17.0945
R557 VDD.t12 VDD.t10 17.0945
R558 VDD.t14 VDD.t12 17.0945
R559 VDD.t72 VDD.t14 17.0945
R560 VDD.t74 VDD.t72 17.0945
R561 VDD.t76 VDD.t74 17.0945
R562 VDD.t78 VDD.t76 17.0945
R563 VDD.n54 VDD.n44 15.6527
R564 VDD.n47 VDD.t40 8.54751
R565 VDD.n47 VDD.t42 8.54751
R566 VDD.n52 VDD.t60 8.54751
R567 VDD.t62 VDD.n52 8.54751
R568 VDD.n44 VDD.n13 7.63093
R569 VDD.n16 VDD.n14 5.73369
R570 VDD.n36 VDD.n34 5.73369
R571 VDD.n16 VDD.n15 5.54421
R572 VDD.n18 VDD.n17 5.54421
R573 VDD.n20 VDD.n19 5.54421
R574 VDD.n22 VDD.n21 5.54421
R575 VDD.n24 VDD.n23 5.54421
R576 VDD.n26 VDD.n25 5.54421
R577 VDD.n28 VDD.n27 5.54421
R578 VDD.n30 VDD.n29 5.54421
R579 VDD.n32 VDD.n31 5.54421
R580 VDD.n43 VDD.n33 5.54421
R581 VDD.n42 VDD.n41 5.54421
R582 VDD.n40 VDD.n39 5.54421
R583 VDD.n38 VDD.n37 5.54421
R584 VDD.n36 VDD.n35 5.54421
R585 VDD.n2 VDD.n0 5.51014
R586 VDD.n10 VDD.n8 5.51014
R587 VDD.n2 VDD.n1 5.32067
R588 VDD.n4 VDD.n3 5.32067
R589 VDD.n6 VDD.n5 5.32067
R590 VDD.n13 VDD.n7 5.32067
R591 VDD.n12 VDD.n11 5.32067
R592 VDD.n10 VDD.n9 5.32067
R593 VDD VDD.n54 5.18721
R594 VDD.n54 VDD.n53 5.14466
R595 VDD.n13 VDD.n6 5.11629
R596 VDD.n44 VDD.n43 4.5005
R597 VDD.n30 VDD.n28 4.35839
R598 VDD.n50 VDD.n49 0.8005
R599 VDD.n53 VDD.n45 0.658705
R600 VDD.n49 VDD.n48 0.6005
R601 VDD.n50 VDD.n45 0.6005
R602 VDD.n0 VDD.t13 0.228
R603 VDD.n0 VDD.t15 0.228
R604 VDD.n1 VDD.t9 0.228
R605 VDD.n1 VDD.t11 0.228
R606 VDD.n3 VDD.t5 0.228
R607 VDD.n3 VDD.t7 0.228
R608 VDD.n5 VDD.t1 0.228
R609 VDD.n5 VDD.t3 0.228
R610 VDD.n7 VDD.t54 0.228
R611 VDD.n7 VDD.t55 0.228
R612 VDD.n11 VDD.t52 0.228
R613 VDD.n11 VDD.t53 0.228
R614 VDD.n9 VDD.t50 0.228
R615 VDD.n9 VDD.t51 0.228
R616 VDD.n8 VDD.t48 0.228
R617 VDD.n8 VDD.t49 0.228
R618 VDD.n12 VDD.n10 0.189974
R619 VDD.n13 VDD.n12 0.189974
R620 VDD.n6 VDD.n4 0.189974
R621 VDD.n4 VDD.n2 0.189974
R622 VDD.n38 VDD.n36 0.189974
R623 VDD.n40 VDD.n38 0.189974
R624 VDD.n42 VDD.n40 0.189974
R625 VDD.n43 VDD.n42 0.189974
R626 VDD.n43 VDD.n32 0.189974
R627 VDD.n32 VDD.n30 0.189974
R628 VDD.n28 VDD.n26 0.189974
R629 VDD.n26 VDD.n24 0.189974
R630 VDD.n24 VDD.n22 0.189974
R631 VDD.n22 VDD.n20 0.189974
R632 VDD.n20 VDD.n18 0.189974
R633 VDD.n18 VDD.n16 0.189974
R634 VDD.n14 VDD.t77 0.152167
R635 VDD.n14 VDD.t79 0.152167
R636 VDD.n15 VDD.t73 0.152167
R637 VDD.n15 VDD.t75 0.152167
R638 VDD.n17 VDD.t70 0.152167
R639 VDD.n17 VDD.t71 0.152167
R640 VDD.n19 VDD.t68 0.152167
R641 VDD.n19 VDD.t69 0.152167
R642 VDD.n21 VDD.t66 0.152167
R643 VDD.n21 VDD.t67 0.152167
R644 VDD.n23 VDD.t64 0.152167
R645 VDD.n23 VDD.t65 0.152167
R646 VDD.n25 VDD.t61 0.152167
R647 VDD.n25 VDD.t63 0.152167
R648 VDD.n27 VDD.t57 0.152167
R649 VDD.n27 VDD.t59 0.152167
R650 VDD.n29 VDD.t45 0.152167
R651 VDD.n29 VDD.t47 0.152167
R652 VDD.n31 VDD.t41 0.152167
R653 VDD.n31 VDD.t43 0.152167
R654 VDD.n33 VDD.t37 0.152167
R655 VDD.n33 VDD.t39 0.152167
R656 VDD.n41 VDD.t33 0.152167
R657 VDD.n41 VDD.t35 0.152167
R658 VDD.n39 VDD.t29 0.152167
R659 VDD.n39 VDD.t31 0.152167
R660 VDD.n37 VDD.t25 0.152167
R661 VDD.n37 VDD.t27 0.152167
R662 VDD.n35 VDD.t21 0.152167
R663 VDD.n35 VDD.t23 0.152167
R664 VDD.n34 VDD.t17 0.152167
R665 VDD.n34 VDD.t19 0.152167
R666 VSS.n106 VSS.n49 488.723
R667 VSS.n92 VSS.n91 488.723
R668 VSS.n92 VSS.n59 488.723
R669 VSS.n76 VSS.n66 488.723
R670 VSS.t46 VSS.n61 366.541
R671 VSS.t56 VSS.n84 366.541
R672 VSS.n68 VSS.n66 244.413
R673 VSS.n106 VSS.n105 244.413
R674 VSS.n55 VSS.n49 244.362
R675 VSS.n91 VSS.n61 244.362
R676 VSS.n84 VSS.n59 244.362
R677 VSS.n76 VSS.n67 244.362
R678 VSS.t16 VSS.n55 122.18
R679 VSS.t78 VSS.n67 122.18
R680 VSS.n100 VSS.n50 105.001
R681 VSS.n100 VSS.n99 105.001
R682 VSS.n99 VSS.n54 105.001
R683 VSS.n60 VSS.n54 105.001
R684 VSS.n83 VSS.n60 105.001
R685 VSS.n83 VSS.n63 105.001
R686 VSS.n77 VSS.n63 105.001
R687 VSS.n77 VSS.n65 105.001
R688 VSS.n104 VSS.n51 105.001
R689 VSS.n97 VSS.n51 105.001
R690 VSS.n97 VSS.n56 105.001
R691 VSS.n93 VSS.n56 105.001
R692 VSS.n93 VSS.n58 105.001
R693 VSS.n71 VSS.n58 105.001
R694 VSS.n75 VSS.n71 105.001
R695 VSS.n75 VSS.n69 105.001
R696 VSS.t18 VSS.t16 48.8727
R697 VSS.t20 VSS.t18 48.8727
R698 VSS.t22 VSS.t20 48.8727
R699 VSS.t24 VSS.t22 48.8727
R700 VSS.t26 VSS.t24 48.8727
R701 VSS.t28 VSS.t26 48.8727
R702 VSS.t30 VSS.t28 48.8727
R703 VSS.t34 VSS.t32 48.8727
R704 VSS.t36 VSS.t34 48.8727
R705 VSS.t38 VSS.t36 48.8727
R706 VSS.t40 VSS.t38 48.8727
R707 VSS.t42 VSS.t44 48.8727
R708 VSS.t44 VSS.t46 48.8727
R709 VSS.t58 VSS.t56 48.8727
R710 VSS.t60 VSS.t58 48.8727
R711 VSS.t0 VSS.t62 48.8727
R712 VSS.t2 VSS.t0 48.8727
R713 VSS.t4 VSS.t2 48.8727
R714 VSS.t6 VSS.t4 48.8727
R715 VSS.t8 VSS.t10 48.8727
R716 VSS.t10 VSS.t12 48.8727
R717 VSS.t12 VSS.t14 48.8727
R718 VSS.t14 VSS.t72 48.8727
R719 VSS.t72 VSS.t74 48.8727
R720 VSS.t74 VSS.t76 48.8727
R721 VSS.t76 VSS.t78 48.8727
R722 VSS.n107 VSS.n106 28.4005
R723 VSS.n55 VSS.n48 28.4005
R724 VSS.n89 VSS.n88 28.4005
R725 VSS.n91 VSS.n90 28.4005
R726 VSS.n87 VSS.n59 28.4005
R727 VSS.n86 VSS.n85 28.4005
R728 VSS.n67 VSS.n62 28.4005
R729 VSS.n66 VSS.n47 28.4005
R730 VSS.n98 VSS.t30 24.4366
R731 VSS.n98 VSS.t32 24.4366
R732 VSS.n88 VSS.t40 24.4366
R733 VSS.n88 VSS.t42 24.4366
R734 VSS.n85 VSS.t60 24.4366
R735 VSS.n85 VSS.t62 24.4366
R736 VSS.n70 VSS.t6 24.4366
R737 VSS.n70 VSS.t8 24.4366
R738 VSS.n46 VSS.n30 9.29398
R739 VSS.n108 VSS.n47 9.1755
R740 VSS.n109 VSS.n46 8.9944
R741 VSS.n103 VSS.n102 6.593
R742 VSS.n72 VSS.n64 6.593
R743 VSS.n33 VSS.n31 5.66497
R744 VSS.n42 VSS.n40 5.66497
R745 VSS.n2 VSS.n0 5.59319
R746 VSS.n23 VSS.n21 5.59319
R747 VSS.n33 VSS.n32 5.4755
R748 VSS.n35 VSS.n34 5.4755
R749 VSS.n37 VSS.n36 5.4755
R750 VSS.n39 VSS.n38 5.4755
R751 VSS.n44 VSS.n43 5.4755
R752 VSS.n42 VSS.n41 5.4755
R753 VSS.n2 VSS.n1 5.40371
R754 VSS.n4 VSS.n3 5.40371
R755 VSS.n6 VSS.n5 5.40371
R756 VSS.n8 VSS.n7 5.40371
R757 VSS.n10 VSS.n9 5.40371
R758 VSS.n12 VSS.n11 5.40371
R759 VSS.n14 VSS.n13 5.40371
R760 VSS.n16 VSS.n15 5.40371
R761 VSS.n18 VSS.n17 5.40371
R762 VSS.n20 VSS.n19 5.40371
R763 VSS.n29 VSS.n28 5.40371
R764 VSS.n27 VSS.n26 5.40371
R765 VSS.n25 VSS.n24 5.40371
R766 VSS.n23 VSS.n22 5.40371
R767 VSS.n104 VSS.n103 5.2005
R768 VSS.n51 VSS.n49 5.2005
R769 VSS.n52 VSS.n51 5.2005
R770 VSS.n98 VSS.n97 5.2005
R771 VSS.n97 VSS.n96 5.2005
R772 VSS.n61 VSS.n56 5.2005
R773 VSS.n95 VSS.n56 5.2005
R774 VSS.n93 VSS.n92 5.2005
R775 VSS.n94 VSS.n93 5.2005
R776 VSS.n84 VSS.n58 5.2005
R777 VSS.n58 VSS.n57 5.2005
R778 VSS.n71 VSS.n70 5.2005
R779 VSS.n73 VSS.n71 5.2005
R780 VSS.n76 VSS.n75 5.2005
R781 VSS.n75 VSS.n74 5.2005
R782 VSS.n72 VSS.n69 5.2005
R783 VSS.n65 VSS.n64 5.2005
R784 VSS.n77 VSS.n76 5.2005
R785 VSS.n78 VSS.n77 5.2005
R786 VSS.n70 VSS.n63 5.2005
R787 VSS.n79 VSS.n63 5.2005
R788 VSS.n84 VSS.n83 5.2005
R789 VSS.n83 VSS.n82 5.2005
R790 VSS.n92 VSS.n60 5.2005
R791 VSS.n81 VSS.n60 5.2005
R792 VSS.n61 VSS.n54 5.2005
R793 VSS.n80 VSS.n54 5.2005
R794 VSS.n99 VSS.n98 5.2005
R795 VSS.n99 VSS.n53 5.2005
R796 VSS.n100 VSS.n49 5.2005
R797 VSS.n101 VSS.n100 5.2005
R798 VSS.n102 VSS.n50 5.2005
R799 VSS VSS.n109 5.18721
R800 VSS.n39 VSS.n37 5.11629
R801 VSS.n69 VSS.n68 5.09763
R802 VSS.n105 VSS.n50 5.09763
R803 VSS.n105 VSS.n104 5.09763
R804 VSS.n68 VSS.n65 5.09763
R805 VSS.n109 VSS.n108 4.5005
R806 VSS.n46 VSS.n45 4.5005
R807 VSS.n16 VSS.n14 4.35839
R808 VSS.n102 VSS.n101 1.3505
R809 VSS.n101 VSS.n53 1.3505
R810 VSS.n80 VSS.n53 1.3505
R811 VSS.n81 VSS.n80 1.3505
R812 VSS.n82 VSS.n81 1.3505
R813 VSS.n82 VSS.n79 1.3505
R814 VSS.n79 VSS.n78 1.3505
R815 VSS.n78 VSS.n64 1.3505
R816 VSS.n103 VSS.n52 1.3505
R817 VSS.n96 VSS.n52 1.3505
R818 VSS.n96 VSS.n95 1.3505
R819 VSS.n95 VSS.n94 1.3505
R820 VSS.n94 VSS.n57 1.3505
R821 VSS.n73 VSS.n57 1.3505
R822 VSS.n74 VSS.n73 1.3505
R823 VSS.n74 VSS.n72 1.3505
R824 VSS.n90 VSS.n87 0.711611
R825 VSS.n89 VSS.n48 0.533833
R826 VSS.n90 VSS.n89 0.533833
R827 VSS.n87 VSS.n86 0.533833
R828 VSS.n86 VSS.n62 0.533833
R829 VSS.n62 VSS.n47 0.533833
R830 VSS.n107 VSS.n48 0.524944
R831 VSS.n0 VSS.t77 0.3281
R832 VSS.n0 VSS.t79 0.3281
R833 VSS.n1 VSS.t73 0.3281
R834 VSS.n1 VSS.t75 0.3281
R835 VSS.n3 VSS.t70 0.3281
R836 VSS.n3 VSS.t71 0.3281
R837 VSS.n5 VSS.t68 0.3281
R838 VSS.n5 VSS.t69 0.3281
R839 VSS.n7 VSS.t66 0.3281
R840 VSS.n7 VSS.t67 0.3281
R841 VSS.n9 VSS.t64 0.3281
R842 VSS.n9 VSS.t65 0.3281
R843 VSS.n11 VSS.t61 0.3281
R844 VSS.n11 VSS.t63 0.3281
R845 VSS.n13 VSS.t57 0.3281
R846 VSS.n13 VSS.t59 0.3281
R847 VSS.n15 VSS.t45 0.3281
R848 VSS.n15 VSS.t47 0.3281
R849 VSS.n17 VSS.t41 0.3281
R850 VSS.n17 VSS.t43 0.3281
R851 VSS.n19 VSS.t37 0.3281
R852 VSS.n19 VSS.t39 0.3281
R853 VSS.n28 VSS.t33 0.3281
R854 VSS.n28 VSS.t35 0.3281
R855 VSS.n26 VSS.t29 0.3281
R856 VSS.n26 VSS.t31 0.3281
R857 VSS.n24 VSS.t25 0.3281
R858 VSS.n24 VSS.t27 0.3281
R859 VSS.n22 VSS.t21 0.3281
R860 VSS.n22 VSS.t23 0.3281
R861 VSS.n21 VSS.t17 0.3281
R862 VSS.n21 VSS.t19 0.3281
R863 VSS.n44 VSS.n42 0.189974
R864 VSS.n37 VSS.n35 0.189974
R865 VSS.n35 VSS.n33 0.189974
R866 VSS.n25 VSS.n23 0.189974
R867 VSS.n27 VSS.n25 0.189974
R868 VSS.n29 VSS.n27 0.189974
R869 VSS.n20 VSS.n18 0.189974
R870 VSS.n18 VSS.n16 0.189974
R871 VSS.n14 VSS.n12 0.189974
R872 VSS.n12 VSS.n10 0.189974
R873 VSS.n10 VSS.n8 0.189974
R874 VSS.n8 VSS.n6 0.189974
R875 VSS.n6 VSS.n4 0.189974
R876 VSS.n4 VSS.n2 0.189974
R877 VSS.n31 VSS.t13 0.1643
R878 VSS.n31 VSS.t15 0.1643
R879 VSS.n32 VSS.t9 0.1643
R880 VSS.n32 VSS.t11 0.1643
R881 VSS.n34 VSS.t5 0.1643
R882 VSS.n34 VSS.t7 0.1643
R883 VSS.n36 VSS.t1 0.1643
R884 VSS.n36 VSS.t3 0.1643
R885 VSS.n38 VSS.t54 0.1643
R886 VSS.n38 VSS.t55 0.1643
R887 VSS.n43 VSS.t52 0.1643
R888 VSS.n43 VSS.t53 0.1643
R889 VSS.n41 VSS.t50 0.1643
R890 VSS.n41 VSS.t51 0.1643
R891 VSS.n40 VSS.t48 0.1643
R892 VSS.n40 VSS.t49 0.1643
R893 VSS.n108 VSS.n107 0.133833
R894 VSS.n45 VSS.n44 0.0952368
R895 VSS.n45 VSS.n39 0.0952368
R896 VSS.n30 VSS.n29 0.0952368
R897 VSS.n30 VSS.n20 0.0952368
C0 VDD E_CAPTURE_CLKB 17.5781f
C1 O_CAPTURE_CLKB O_WRITE 3.37239f
C2 E_CAPTURE_CLK VDD 31.1587f
C3 O_CAPTURE_CLKB VDD 17.2532f
C4 O_CAPTURE_CLKB O_CAPTURE_CLK 6.98777f
C5 E_WRITE VDD 3.1239f
C6 VDD O_WRITE 3.07771f
C7 O_CAPTURE_CLK O_WRITE 1.83769f
C8 O_CAPTURE_CLK VDD 31.1009f
C9 E_CAPTURE_CLK E_CAPTURE_CLKB 7.0214f
C10 E_WRITE E_CAPTURE_CLKB 3.14838f
C11 E_CAPTURE_CLK E_WRITE 1.72904f
C12 O_WRITE VSS 7.89106f
C13 E_WRITE VSS 8.56752f
C14 O_CAPTURE_CLK VSS 17.66757f
C15 E_CAPTURE_CLK VSS 17.71886f
C16 O_CAPTURE_CLKB VSS 23.05506f
C17 E_CAPTURE_CLKB VSS 23.0735f
C18 VDD VSS 0.59304p
C19 VSS.t79 VSS 0.06449f
C20 VSS.t77 VSS 0.06234f
C21 VSS.t75 VSS 0.06234f
C22 VSS.t73 VSS 0.06234f
C23 VSS.t71 VSS 0.06234f
C24 VSS.t70 VSS 0.06234f
C25 VSS.t69 VSS 0.06234f
C26 VSS.t68 VSS 0.06234f
C27 VSS.t67 VSS 0.06234f
C28 VSS.t66 VSS 0.06234f
C29 VSS.t65 VSS 0.06234f
C30 VSS.t64 VSS 0.06234f
C31 VSS.t63 VSS 0.06234f
C32 VSS.t61 VSS 0.06234f
C33 VSS.t59 VSS 0.06234f
C34 VSS.t57 VSS 0.06449f
C35 VSS.t47 VSS 0.06543f
C36 VSS.t45 VSS 0.06326f
C37 VSS.t43 VSS 0.06326f
C38 VSS.t41 VSS 0.06326f
C39 VSS.t39 VSS 0.06326f
C40 VSS.t37 VSS 0.06326f
C41 VSS.t19 VSS 0.06326f
C42 VSS.t17 VSS 0.06543f
C43 VSS.t23 VSS 0.06326f
C44 VSS.t21 VSS 0.06326f
C45 VSS.t27 VSS 0.06326f
C46 VSS.t25 VSS 0.06326f
C47 VSS.t31 VSS 0.06326f
C48 VSS.t29 VSS 0.06326f
C49 VSS.t35 VSS 0.06326f
C50 VSS.t33 VSS 0.06326f
C51 VSS.t15 VSS 0.09028f
C52 VSS.t13 VSS 0.08898f
C53 VSS.t11 VSS 0.08898f
C54 VSS.t9 VSS 0.08898f
C55 VSS.t7 VSS 0.08898f
C56 VSS.t5 VSS 0.08898f
C57 VSS.t3 VSS 0.08898f
C58 VSS.t1 VSS 0.09028f
C59 VSS.t55 VSS 0.08665f
C60 VSS.t54 VSS 0.0854f
C61 VSS.t49 VSS 0.0854f
C62 VSS.t48 VSS 0.08665f
C63 VSS.t51 VSS 0.0854f
C64 VSS.t50 VSS 0.0854f
C65 VSS.t53 VSS 0.0854f
C66 VSS.t52 VSS 0.0854f
C67 VDD.t15 VSS 0.09329f
C68 VDD.t13 VSS 0.09191f
C69 VDD.n0 VSS 0.10437f
C70 VDD.t11 VSS 0.09191f
C71 VDD.t9 VSS 0.09191f
C72 VDD.n1 VSS 0.10356f
C73 VDD.n2 VSS 0.05248f
C74 VDD.t7 VSS 0.09191f
C75 VDD.t5 VSS 0.09191f
C76 VDD.n3 VSS 0.10356f
C77 VDD.n4 VSS 0.02972f
C78 VDD.t3 VSS 0.09191f
C79 VDD.t1 VSS 0.09329f
C80 VDD.n5 VSS 0.10356f
C81 VDD.n6 VSS 0.33381f
C82 VDD.t55 VSS 0.09034f
C83 VDD.t54 VSS 0.08902f
C84 VDD.n7 VSS 0.10356f
C85 VDD.t49 VSS 0.08902f
C86 VDD.t48 VSS 0.09034f
C87 VDD.n8 VSS 0.10437f
C88 VDD.t51 VSS 0.08902f
C89 VDD.t50 VSS 0.08902f
C90 VDD.n9 VSS 0.10356f
C91 VDD.n10 VSS 0.05248f
C92 VDD.t53 VSS 0.08902f
C93 VDD.t52 VSS 0.08902f
C94 VDD.n11 VSS 0.10356f
C95 VDD.n12 VSS 0.02972f
C96 VDD.n13 VSS 0.36879f
C97 VDD.t79 VSS 0.17454f
C98 VDD.t77 VSS 0.17286f
C99 VDD.n14 VSS 0.15699f
C100 VDD.t75 VSS 0.17286f
C101 VDD.t73 VSS 0.17286f
C102 VDD.n15 VSS 0.15611f
C103 VDD.n16 VSS 0.05811f
C104 VDD.t71 VSS 0.17286f
C105 VDD.t70 VSS 0.17286f
C106 VDD.n17 VSS 0.15611f
C107 VDD.n18 VSS 0.03256f
C108 VDD.t69 VSS 0.17286f
C109 VDD.t68 VSS 0.17286f
C110 VDD.n19 VSS 0.15611f
C111 VDD.n20 VSS 0.03256f
C112 VDD.t67 VSS 0.17286f
C113 VDD.t66 VSS 0.17286f
C114 VDD.n21 VSS 0.15611f
C115 VDD.n22 VSS 0.03256f
C116 VDD.t65 VSS 0.17286f
C117 VDD.t64 VSS 0.17286f
C118 VDD.n23 VSS 0.15611f
C119 VDD.n24 VSS 0.03256f
C120 VDD.t63 VSS 0.17286f
C121 VDD.t61 VSS 0.17286f
C122 VDD.n25 VSS 0.15611f
C123 VDD.n26 VSS 0.03256f
C124 VDD.t59 VSS 0.17286f
C125 VDD.t57 VSS 0.17454f
C126 VDD.n27 VSS 0.15611f
C127 VDD.n28 VSS 0.28988f
C128 VDD.t47 VSS 0.17666f
C129 VDD.t45 VSS 0.17495f
C130 VDD.n29 VSS 0.15611f
C131 VDD.n30 VSS 0.28988f
C132 VDD.t43 VSS 0.17495f
C133 VDD.t41 VSS 0.17495f
C134 VDD.n31 VSS 0.15611f
C135 VDD.n32 VSS 0.03256f
C136 VDD.t39 VSS 0.17495f
C137 VDD.t37 VSS 0.17495f
C138 VDD.n33 VSS 0.15611f
C139 VDD.t19 VSS 0.17495f
C140 VDD.t17 VSS 0.17666f
C141 VDD.n34 VSS 0.15699f
C142 VDD.t23 VSS 0.17495f
C143 VDD.t21 VSS 0.17495f
C144 VDD.n35 VSS 0.15611f
C145 VDD.n36 VSS 0.05811f
C146 VDD.t27 VSS 0.17495f
C147 VDD.t25 VSS 0.17495f
C148 VDD.n37 VSS 0.15611f
C149 VDD.n38 VSS 0.03256f
C150 VDD.t31 VSS 0.17495f
C151 VDD.t29 VSS 0.17495f
C152 VDD.n39 VSS 0.15611f
C153 VDD.n40 VSS 0.03256f
C154 VDD.t35 VSS 0.17495f
C155 VDD.t33 VSS 0.17495f
C156 VDD.n41 VSS 0.15611f
C157 VDD.n42 VSS 0.03256f
C158 VDD.n43 VSS 0.03256f
C159 VDD.n44 VSS 0.51408f
C160 VDD.n45 VSS 0.22584f
C161 VDD.n46 VSS 11.7244f
C162 VDD.t16 VSS 4.42073f
C163 VDD.t46 VSS 4.86156f
C164 VDD.t44 VSS 0.72023f
C165 VDD.t42 VSS 0.54017f
C166 VDD.t18 VSS 0.72023f
C167 VDD.t20 VSS 0.72023f
C168 VDD.t22 VSS 0.72023f
C169 VDD.t24 VSS 0.72023f
C170 VDD.t26 VSS 0.72023f
C171 VDD.t28 VSS 0.72023f
C172 VDD.t30 VSS 0.72023f
C173 VDD.t32 VSS 0.72023f
C174 VDD.t34 VSS 0.72023f
C175 VDD.t36 VSS 0.72023f
C176 VDD.t38 VSS 0.72023f
C177 VDD.t40 VSS 0.54017f
C178 VDD.n47 VSS 0.38075f
C179 VDD.n48 VSS 16.3326f
C180 VDD.n49 VSS 0.23827f
C181 VDD.n50 VSS 0.23827f
C182 VDD.n51 VSS 11.7244f
C183 VDD.t56 VSS 4.86156f
C184 VDD.t58 VSS 0.72023f
C185 VDD.t60 VSS 0.54017f
C186 VDD.n52 VSS 0.38075f
C187 VDD.t62 VSS 0.54017f
C188 VDD.t0 VSS 0.72023f
C189 VDD.t2 VSS 0.72023f
C190 VDD.t4 VSS 0.72023f
C191 VDD.t6 VSS 0.72023f
C192 VDD.t8 VSS 0.72023f
C193 VDD.t10 VSS 0.72023f
C194 VDD.t12 VSS 0.72023f
C195 VDD.t14 VSS 0.72023f
C196 VDD.t72 VSS 0.72023f
C197 VDD.t74 VSS 0.72023f
C198 VDD.t76 VSS 0.72023f
C199 VDD.t78 VSS 4.27001f
C200 VDD.n53 VSS 15.0962f
C201 VDD.n54 VSS 2.04301f
C202 E_CAPTURE_CLKB.n0 VSS 0.06114f
C203 E_CAPTURE_CLKB.n1 VSS 0.06515f
C204 E_CAPTURE_CLKB.n2 VSS 0.13237f
C205 E_CAPTURE_CLKB.n3 VSS 0.13237f
C206 E_CAPTURE_CLKB.n4 VSS 0.12593f
C207 E_CAPTURE_CLKB.n5 VSS 0.19108f
C208 E_CAPTURE_CLKB.n6 VSS 0.06565f
C209 E_CAPTURE_CLKB.n7 VSS 0.13237f
C210 E_CAPTURE_CLKB.n8 VSS 0.13237f
C211 E_CAPTURE_CLKB.n9 VSS 0.06515f
C212 E_CAPTURE_CLKB.n10 VSS 0.06565f
C213 E_CAPTURE_CLKB.n11 VSS 0.06565f
C214 E_CAPTURE_CLKB.n12 VSS 0.06565f
C215 E_CAPTURE_CLKB.n13 VSS 0.06565f
C216 E_CAPTURE_CLKB.n14 VSS 0.06565f
C217 E_CAPTURE_CLKB.n15 VSS 0.19108f
C218 E_CAPTURE_CLKB.n16 VSS 0.12593f
C219 E_CAPTURE_CLKB.n17 VSS 0.13237f
C220 E_CAPTURE_CLKB.n18 VSS 0.13237f
C221 E_CAPTURE_CLKB.n19 VSS 0.13237f
C222 E_CAPTURE_CLKB.n20 VSS 0.13237f
C223 E_CAPTURE_CLKB.n21 VSS 0.13237f
C224 E_CAPTURE_CLKB.n22 VSS 0.13237f
C225 E_CAPTURE_CLKB.n23 VSS 0.13237f
C226 E_CAPTURE_CLKB.n24 VSS 0.13237f
C227 E_CAPTURE_CLKB.n25 VSS 0.13237f
C228 E_CAPTURE_CLKB.n26 VSS 0.13237f
C229 E_CAPTURE_CLKB.n27 VSS 0.06114f
C230 E_CAPTURE_CLKB.n28 VSS 0.09706f
C231 E_CAPTURE_CLKB.t11 VSS 0.80775f
C232 E_CAPTURE_CLKB.t8 VSS 0.18461f
C233 E_CAPTURE_CLKB.t0 VSS 0.18461f
C234 E_CAPTURE_CLKB.n29 VSS 0.59835f
C235 E_CAPTURE_CLKB.n30 VSS 0.32889f
C236 E_CAPTURE_CLKB.t3 VSS 0.18461f
C237 E_CAPTURE_CLKB.t12 VSS 0.18461f
C238 E_CAPTURE_CLKB.n31 VSS 0.59835f
C239 E_CAPTURE_CLKB.n32 VSS 0.17169f
C240 E_CAPTURE_CLKB.t15 VSS 0.18461f
C241 E_CAPTURE_CLKB.t13 VSS 0.18461f
C242 E_CAPTURE_CLKB.n33 VSS 0.59835f
C243 E_CAPTURE_CLKB.t14 VSS 0.80775f
C244 E_CAPTURE_CLKB.n34 VSS 0.32889f
C245 E_CAPTURE_CLKB.n35 VSS 1.28004f
C246 E_CAPTURE_CLKB.n36 VSS 0.06114f
C247 E_CAPTURE_CLKB.n37 VSS 0.06515f
C248 E_CAPTURE_CLKB.n38 VSS 0.06565f
C249 E_CAPTURE_CLKB.n39 VSS 0.19108f
C250 E_CAPTURE_CLKB.n40 VSS 0.07051f
C251 E_CAPTURE_CLKB.n41 VSS 0.07788f
C252 E_CAPTURE_CLKB.n42 VSS 0.07788f
C253 E_CAPTURE_CLKB.n43 VSS 0.07788f
C254 E_CAPTURE_CLKB.n44 VSS 0.07788f
C255 E_CAPTURE_CLKB.n45 VSS 0.07788f
C256 E_CAPTURE_CLKB.n46 VSS 0.06565f
C257 E_CAPTURE_CLKB.n47 VSS 0.07788f
C258 E_CAPTURE_CLKB.n48 VSS 0.07051f
C259 E_CAPTURE_CLKB.n49 VSS 0.07788f
C260 E_CAPTURE_CLKB.n50 VSS 0.07788f
C261 E_CAPTURE_CLKB.n51 VSS 0.19108f
C262 E_CAPTURE_CLKB.n52 VSS 0.06565f
C263 E_CAPTURE_CLKB.n53 VSS 0.06565f
C264 E_CAPTURE_CLKB.n54 VSS 0.07788f
C265 E_CAPTURE_CLKB.n55 VSS 0.07788f
C266 E_CAPTURE_CLKB.n56 VSS 0.07788f
C267 E_CAPTURE_CLKB.n57 VSS 0.06565f
C268 E_CAPTURE_CLKB.n58 VSS 0.06565f
C269 E_CAPTURE_CLKB.n59 VSS 0.06515f
C270 E_CAPTURE_CLKB.n60 VSS 0.07788f
C271 E_CAPTURE_CLKB.n61 VSS 0.07788f
C272 E_CAPTURE_CLKB.n62 VSS 0.07788f
C273 E_CAPTURE_CLKB.n63 VSS 0.06114f
C274 E_CAPTURE_CLKB.n64 VSS 0.05177f
C275 E_CAPTURE_CLKB.n65 VSS 1.07808f
C276 E_CAPTURE_CLKB.t2 VSS 1.01539f
C277 E_CAPTURE_CLKB.t1 VSS 0.2299f
C278 E_CAPTURE_CLKB.t5 VSS 0.2299f
C279 E_CAPTURE_CLKB.n66 VSS 0.74639f
C280 E_CAPTURE_CLKB.n67 VSS 0.34966f
C281 E_CAPTURE_CLKB.t4 VSS 0.2299f
C282 E_CAPTURE_CLKB.t10 VSS 0.2299f
C283 E_CAPTURE_CLKB.n68 VSS 0.74639f
C284 E_CAPTURE_CLKB.n69 VSS 0.18371f
C285 E_CAPTURE_CLKB.t7 VSS 0.2299f
C286 E_CAPTURE_CLKB.t9 VSS 0.2299f
C287 E_CAPTURE_CLKB.n70 VSS 0.74639f
C288 E_CAPTURE_CLKB.t6 VSS 1.01539f
C289 E_CAPTURE_CLKB.n71 VSS 0.38529f
C290 E_CAPTURE_CLKB.n72 VSS 1.46273f
C291 O_CAPTURE_CLKB.n0 VSS 0.06026f
C292 O_CAPTURE_CLKB.n1 VSS 0.06421f
C293 O_CAPTURE_CLKB.n2 VSS 0.13046f
C294 O_CAPTURE_CLKB.n3 VSS 0.13046f
C295 O_CAPTURE_CLKB.n4 VSS 0.12411f
C296 O_CAPTURE_CLKB.n5 VSS 0.18832f
C297 O_CAPTURE_CLKB.n6 VSS 0.0647f
C298 O_CAPTURE_CLKB.n7 VSS 0.13046f
C299 O_CAPTURE_CLKB.n8 VSS 0.13046f
C300 O_CAPTURE_CLKB.n9 VSS 0.06421f
C301 O_CAPTURE_CLKB.n10 VSS 0.0647f
C302 O_CAPTURE_CLKB.n11 VSS 0.0647f
C303 O_CAPTURE_CLKB.n12 VSS 0.0647f
C304 O_CAPTURE_CLKB.n13 VSS 0.0647f
C305 O_CAPTURE_CLKB.n14 VSS 0.0647f
C306 O_CAPTURE_CLKB.n15 VSS 0.18832f
C307 O_CAPTURE_CLKB.n16 VSS 0.12411f
C308 O_CAPTURE_CLKB.n17 VSS 0.13046f
C309 O_CAPTURE_CLKB.n18 VSS 0.13046f
C310 O_CAPTURE_CLKB.n19 VSS 0.13046f
C311 O_CAPTURE_CLKB.n20 VSS 0.13046f
C312 O_CAPTURE_CLKB.n21 VSS 0.13046f
C313 O_CAPTURE_CLKB.n22 VSS 0.13046f
C314 O_CAPTURE_CLKB.n23 VSS 0.13046f
C315 O_CAPTURE_CLKB.n24 VSS 0.13046f
C316 O_CAPTURE_CLKB.n25 VSS 0.13046f
C317 O_CAPTURE_CLKB.n26 VSS 0.13046f
C318 O_CAPTURE_CLKB.n27 VSS 0.06026f
C319 O_CAPTURE_CLKB.n28 VSS 0.09566f
C320 O_CAPTURE_CLKB.t5 VSS 0.80004f
C321 O_CAPTURE_CLKB.t11 VSS 0.18583f
C322 O_CAPTURE_CLKB.t6 VSS 0.18583f
C323 O_CAPTURE_CLKB.n29 VSS 0.58971f
C324 O_CAPTURE_CLKB.n30 VSS 0.32414f
C325 O_CAPTURE_CLKB.t7 VSS 0.18583f
C326 O_CAPTURE_CLKB.t2 VSS 0.18583f
C327 O_CAPTURE_CLKB.n31 VSS 0.58971f
C328 O_CAPTURE_CLKB.n32 VSS 0.16921f
C329 O_CAPTURE_CLKB.t12 VSS 0.18583f
C330 O_CAPTURE_CLKB.t8 VSS 0.18583f
C331 O_CAPTURE_CLKB.n33 VSS 0.58971f
C332 O_CAPTURE_CLKB.t15 VSS 0.80004f
C333 O_CAPTURE_CLKB.n34 VSS 0.32414f
C334 O_CAPTURE_CLKB.n35 VSS 1.26154f
C335 O_CAPTURE_CLKB.n36 VSS 0.06026f
C336 O_CAPTURE_CLKB.n37 VSS 0.06421f
C337 O_CAPTURE_CLKB.n38 VSS 0.0647f
C338 O_CAPTURE_CLKB.n39 VSS 0.18832f
C339 O_CAPTURE_CLKB.n40 VSS 0.06949f
C340 O_CAPTURE_CLKB.n41 VSS 0.07676f
C341 O_CAPTURE_CLKB.n42 VSS 0.07676f
C342 O_CAPTURE_CLKB.n43 VSS 0.07676f
C343 O_CAPTURE_CLKB.n44 VSS 0.07676f
C344 O_CAPTURE_CLKB.n45 VSS 0.07676f
C345 O_CAPTURE_CLKB.n46 VSS 0.0647f
C346 O_CAPTURE_CLKB.n47 VSS 0.07676f
C347 O_CAPTURE_CLKB.n48 VSS 0.06949f
C348 O_CAPTURE_CLKB.n49 VSS 0.07676f
C349 O_CAPTURE_CLKB.n50 VSS 0.07676f
C350 O_CAPTURE_CLKB.n51 VSS 0.18832f
C351 O_CAPTURE_CLKB.n52 VSS 0.0647f
C352 O_CAPTURE_CLKB.n53 VSS 0.0647f
C353 O_CAPTURE_CLKB.n54 VSS 0.07676f
C354 O_CAPTURE_CLKB.n55 VSS 0.07676f
C355 O_CAPTURE_CLKB.n56 VSS 0.07676f
C356 O_CAPTURE_CLKB.n57 VSS 0.0647f
C357 O_CAPTURE_CLKB.n58 VSS 0.0647f
C358 O_CAPTURE_CLKB.n59 VSS 0.06421f
C359 O_CAPTURE_CLKB.n60 VSS 0.07676f
C360 O_CAPTURE_CLKB.n61 VSS 0.07676f
C361 O_CAPTURE_CLKB.n62 VSS 0.07676f
C362 O_CAPTURE_CLKB.n63 VSS 0.06026f
C363 O_CAPTURE_CLKB.n64 VSS 0.05103f
C364 O_CAPTURE_CLKB.n65 VSS 0.86094f
C365 O_CAPTURE_CLKB.t3 VSS 1.0056f
C366 O_CAPTURE_CLKB.t1 VSS 0.23138f
C367 O_CAPTURE_CLKB.t10 VSS 0.23138f
C368 O_CAPTURE_CLKB.n66 VSS 0.7356f
C369 O_CAPTURE_CLKB.n67 VSS 0.34461f
C370 O_CAPTURE_CLKB.t0 VSS 0.23138f
C371 O_CAPTURE_CLKB.t9 VSS 0.23138f
C372 O_CAPTURE_CLKB.n68 VSS 0.7356f
C373 O_CAPTURE_CLKB.n69 VSS 0.18105f
C374 O_CAPTURE_CLKB.t4 VSS 0.23138f
C375 O_CAPTURE_CLKB.t13 VSS 0.23138f
C376 O_CAPTURE_CLKB.n70 VSS 0.7356f
C377 O_CAPTURE_CLKB.t14 VSS 1.0056f
C378 O_CAPTURE_CLKB.n71 VSS 0.48938f
C379 O_CAPTURE_CLKB.n72 VSS 1.66604f
C380 E_CAPTURE_CLK.t25 VSS 2.07786f
C381 E_CAPTURE_CLK.t26 VSS 0.44338f
C382 E_CAPTURE_CLK.t0 VSS 0.44338f
C383 E_CAPTURE_CLK.n0 VSS 1.5525f
C384 E_CAPTURE_CLK.n1 VSS 0.62107f
C385 E_CAPTURE_CLK.t1 VSS 0.44338f
C386 E_CAPTURE_CLK.t23 VSS 0.44338f
C387 E_CAPTURE_CLK.n2 VSS 1.5525f
C388 E_CAPTURE_CLK.n3 VSS 0.32381f
C389 E_CAPTURE_CLK.t24 VSS 0.44338f
C390 E_CAPTURE_CLK.t28 VSS 0.44338f
C391 E_CAPTURE_CLK.n4 VSS 1.5525f
C392 E_CAPTURE_CLK.n5 VSS 0.32381f
C393 E_CAPTURE_CLK.t29 VSS 0.44338f
C394 E_CAPTURE_CLK.t21 VSS 0.44338f
C395 E_CAPTURE_CLK.n6 VSS 1.5525f
C396 E_CAPTURE_CLK.n7 VSS 0.26566f
C397 E_CAPTURE_CLK.t15 VSS 2.07786f
C398 E_CAPTURE_CLK.t11 VSS 0.44338f
C399 E_CAPTURE_CLK.t14 VSS 0.44338f
C400 E_CAPTURE_CLK.n8 VSS 1.5525f
C401 E_CAPTURE_CLK.n9 VSS 0.62107f
C402 E_CAPTURE_CLK.t4 VSS 0.44338f
C403 E_CAPTURE_CLK.t10 VSS 0.44338f
C404 E_CAPTURE_CLK.n10 VSS 1.5525f
C405 E_CAPTURE_CLK.n11 VSS 0.32381f
C406 E_CAPTURE_CLK.t22 VSS 0.44338f
C407 E_CAPTURE_CLK.t3 VSS 0.44338f
C408 E_CAPTURE_CLK.n12 VSS 1.5525f
C409 E_CAPTURE_CLK.n13 VSS 0.26566f
C410 E_CAPTURE_CLK.n14 VSS 1.41127f
C411 E_CAPTURE_CLK.t18 VSS 0.82928f
C412 E_CAPTURE_CLK.t27 VSS 0.18761f
C413 E_CAPTURE_CLK.t9 VSS 0.18761f
C414 E_CAPTURE_CLK.n15 VSS 0.62135f
C415 E_CAPTURE_CLK.n16 VSS 0.55019f
C416 E_CAPTURE_CLK.t2 VSS 0.18761f
C417 E_CAPTURE_CLK.t8 VSS 0.18761f
C418 E_CAPTURE_CLK.n17 VSS 0.62135f
C419 E_CAPTURE_CLK.n18 VSS 0.29079f
C420 E_CAPTURE_CLK.t7 VSS 0.18761f
C421 E_CAPTURE_CLK.t30 VSS 0.18761f
C422 E_CAPTURE_CLK.n19 VSS 0.62135f
C423 E_CAPTURE_CLK.n20 VSS 0.29079f
C424 E_CAPTURE_CLK.t31 VSS 0.18761f
C425 E_CAPTURE_CLK.t19 VSS 0.18761f
C426 E_CAPTURE_CLK.n21 VSS 0.62135f
C427 E_CAPTURE_CLK.n22 VSS 0.23263f
C428 E_CAPTURE_CLK.t17 VSS 0.82928f
C429 E_CAPTURE_CLK.t13 VSS 0.18761f
C430 E_CAPTURE_CLK.t16 VSS 0.18761f
C431 E_CAPTURE_CLK.n23 VSS 0.62135f
C432 E_CAPTURE_CLK.n24 VSS 0.55019f
C433 E_CAPTURE_CLK.t6 VSS 0.18761f
C434 E_CAPTURE_CLK.t12 VSS 0.18761f
C435 E_CAPTURE_CLK.n25 VSS 0.62135f
C436 E_CAPTURE_CLK.n26 VSS 0.29079f
C437 E_CAPTURE_CLK.t20 VSS 0.18761f
C438 E_CAPTURE_CLK.t5 VSS 0.18761f
C439 E_CAPTURE_CLK.n27 VSS 0.62135f
C440 E_CAPTURE_CLK.n28 VSS 0.23263f
C441 E_CAPTURE_CLK.n29 VSS 0.1386f
C442 E_CAPTURE_CLK.n30 VSS 4.67053f
C443 O_CAPTURE_CLK.t17 VSS 2.06538f
C444 O_CAPTURE_CLK.t18 VSS 0.43968f
C445 O_CAPTURE_CLK.t12 VSS 0.43968f
C446 O_CAPTURE_CLK.n0 VSS 1.54417f
C447 O_CAPTURE_CLK.n1 VSS 0.61774f
C448 O_CAPTURE_CLK.t13 VSS 0.43968f
C449 O_CAPTURE_CLK.t4 VSS 0.43968f
C450 O_CAPTURE_CLK.n2 VSS 1.54417f
C451 O_CAPTURE_CLK.n3 VSS 0.32208f
C452 O_CAPTURE_CLK.t5 VSS 0.43968f
C453 O_CAPTURE_CLK.t25 VSS 0.43968f
C454 O_CAPTURE_CLK.n4 VSS 1.54417f
C455 O_CAPTURE_CLK.n5 VSS 0.32208f
C456 O_CAPTURE_CLK.t26 VSS 0.43968f
C457 O_CAPTURE_CLK.t0 VSS 0.43968f
C458 O_CAPTURE_CLK.n6 VSS 1.54417f
C459 O_CAPTURE_CLK.n7 VSS 0.26423f
C460 O_CAPTURE_CLK.t31 VSS 2.06538f
C461 O_CAPTURE_CLK.t23 VSS 0.43968f
C462 O_CAPTURE_CLK.t30 VSS 0.43968f
C463 O_CAPTURE_CLK.n8 VSS 1.54417f
C464 O_CAPTURE_CLK.n9 VSS 0.61774f
C465 O_CAPTURE_CLK.t9 VSS 0.43968f
C466 O_CAPTURE_CLK.t22 VSS 0.43968f
C467 O_CAPTURE_CLK.n10 VSS 1.54417f
C468 O_CAPTURE_CLK.n11 VSS 0.32208f
C469 O_CAPTURE_CLK.t1 VSS 0.43968f
C470 O_CAPTURE_CLK.t8 VSS 0.43968f
C471 O_CAPTURE_CLK.n12 VSS 1.54417f
C472 O_CAPTURE_CLK.n13 VSS 0.26423f
C473 O_CAPTURE_CLK.n14 VSS 1.09618f
C474 O_CAPTURE_CLK.t15 VSS 0.82424f
C475 O_CAPTURE_CLK.t10 VSS 0.18603f
C476 O_CAPTURE_CLK.t29 VSS 0.18603f
C477 O_CAPTURE_CLK.n15 VSS 0.61802f
C478 O_CAPTURE_CLK.n16 VSS 0.54724f
C479 O_CAPTURE_CLK.t14 VSS 0.18603f
C480 O_CAPTURE_CLK.t6 VSS 0.18603f
C481 O_CAPTURE_CLK.n17 VSS 0.61802f
C482 O_CAPTURE_CLK.n18 VSS 0.28923f
C483 O_CAPTURE_CLK.t19 VSS 0.18603f
C484 O_CAPTURE_CLK.t7 VSS 0.18603f
C485 O_CAPTURE_CLK.n19 VSS 0.61802f
C486 O_CAPTURE_CLK.n20 VSS 0.28923f
C487 O_CAPTURE_CLK.t2 VSS 0.18603f
C488 O_CAPTURE_CLK.t11 VSS 0.18603f
C489 O_CAPTURE_CLK.n21 VSS 0.61802f
C490 O_CAPTURE_CLK.n22 VSS 0.23139f
C491 O_CAPTURE_CLK.t21 VSS 0.82424f
C492 O_CAPTURE_CLK.t28 VSS 0.18603f
C493 O_CAPTURE_CLK.t20 VSS 0.18603f
C494 O_CAPTURE_CLK.n23 VSS 0.61802f
C495 O_CAPTURE_CLK.n24 VSS 0.54724f
C496 O_CAPTURE_CLK.t16 VSS 0.18603f
C497 O_CAPTURE_CLK.t27 VSS 0.18603f
C498 O_CAPTURE_CLK.n25 VSS 0.61802f
C499 O_CAPTURE_CLK.n26 VSS 0.28923f
C500 O_CAPTURE_CLK.t3 VSS 0.18603f
C501 O_CAPTURE_CLK.t24 VSS 0.18603f
C502 O_CAPTURE_CLK.n27 VSS 0.61802f
C503 O_CAPTURE_CLK.n28 VSS 0.23139f
C504 O_CAPTURE_CLK.n29 VSS 0.2994f
C505 O_CAPTURE_CLK.n30 VSS 4.90658f
C506 E_WRITE.n0 VSS 0.04294f
C507 E_WRITE.n1 VSS 0.13385f
C508 E_WRITE.n2 VSS 0.06633f
C509 E_WRITE.n3 VSS 0.0711f
C510 E_WRITE.n4 VSS 0.0711f
C511 E_WRITE.n5 VSS 0.13385f
C512 E_WRITE.n6 VSS 0.06633f
C513 E_WRITE.n7 VSS 0.0711f
C514 E_WRITE.n8 VSS 0.0711f
C515 E_WRITE.n9 VSS 0.0711f
C516 E_WRITE.n10 VSS 0.0711f
C517 E_WRITE.n11 VSS 0.04294f
C518 E_WRITE.n12 VSS 0.4828f
C519 E_WRITE.n13 VSS 0.04294f
C520 E_WRITE.n14 VSS 0.13385f
C521 E_WRITE.n15 VSS 0.07741f
C522 E_WRITE.n16 VSS 0.08203f
C523 E_WRITE.n17 VSS 0.08203f
C524 E_WRITE.n18 VSS 0.08203f
C525 E_WRITE.n19 VSS 0.07741f
C526 E_WRITE.n20 VSS 0.13385f
C527 E_WRITE.n21 VSS 0.08203f
C528 E_WRITE.n22 VSS 0.08203f
C529 E_WRITE.n23 VSS 0.08203f
C530 E_WRITE.n24 VSS 0.04294f
C531 E_WRITE.n25 VSS 0.03636f
C532 E_WRITE.n26 VSS 2.17909f
C533 O_WRITE.n0 VSS 0.04474f
C534 O_WRITE.n1 VSS 0.13945f
C535 O_WRITE.n2 VSS 0.06911f
C536 O_WRITE.n3 VSS 0.07408f
C537 O_WRITE.n4 VSS 0.07408f
C538 O_WRITE.n5 VSS 0.13945f
C539 O_WRITE.n6 VSS 0.06911f
C540 O_WRITE.n7 VSS 0.07408f
C541 O_WRITE.n8 VSS 0.07408f
C542 O_WRITE.n9 VSS 0.07408f
C543 O_WRITE.n10 VSS 0.07408f
C544 O_WRITE.n11 VSS 0.04474f
C545 O_WRITE.n12 VSS 0.42251f
C546 O_WRITE.n13 VSS 0.04474f
C547 O_WRITE.n14 VSS 0.13945f
C548 O_WRITE.n15 VSS 0.08065f
C549 O_WRITE.n16 VSS 0.08547f
C550 O_WRITE.n17 VSS 0.08547f
C551 O_WRITE.n18 VSS 0.08547f
C552 O_WRITE.n19 VSS 0.08065f
C553 O_WRITE.n20 VSS 0.13945f
C554 O_WRITE.n21 VSS 0.08547f
C555 O_WRITE.n22 VSS 0.08547f
C556 O_WRITE.n23 VSS 0.08547f
C557 O_WRITE.n24 VSS 0.04474f
C558 O_WRITE.n25 VSS 0.05733f
C559 O_WRITE.n26 VSS 2.30099f
.ends
