* SPDX-License-Identifier: Apache-2.0
* Clocked regenerative differential CML-to-CMOS sense amplifier.
.subckt cml_to_cmos INP INN SENSE_CLK VDD VSS OUTP OUTN
* Both internal nodes precharge high while SENSE_CLK is low.
XPREP XP SENSE_CLK VDD VDD pfet_03v3 w=8u l=0.28u m=4
XPREN XN SENSE_CLK VDD VDD pfet_03v3 w=8u l=0.28u m=4
XEQUAL XP SENSE_CLK XN VDD pfet_03v3 w=8u l=0.28u m=4
XLATP XP XN VDD VDD pfet_03v3 w=8u l=0.28u m=5
XLATN XN XP VDD VDD pfet_03v3 w=8u l=0.28u m=5

* The high input discharges its node first.  Cross-coupled helpers regenerate
* the differential decision after the clocked tail enables evaluation.
XIP XP INP NTAIL VSS nfet_03v3 w=8u l=0.28u m=2
XIN XN INN NTAIL VSS nfet_03v3 w=8u l=0.28u m=2
XREGENP XP XN NTAIL VSS nfet_03v3 w=8u l=0.28u m=3
XREGENN XN XP NTAIL VSS nfet_03v3 w=8u l=0.28u m=3
XTAIL NTAIL SENSE_CLK VSS VSS nfet_03v3 w=8u l=0.28u m=8

* A cross-coupled inverter pair stores the decision.  A falling sense node
* turns on one PMOS set device: XP sets QP high and XN sets QN high.  Once the
* sense nodes precharge high, both set devices turn off and the inverter pair
* retains its state.  Gate-only sensing prevents the held nodes from feeding
* charge back into the dynamic sensor.
XLP QP QN VDD VDD pfet_03v3 w=4u l=0.28u m=1
XLN QP QN VSS VSS nfet_03v3 w=4u l=0.28u m=1
XRP QN QP VDD VDD pfet_03v3 w=4u l=0.28u m=1
XRN QN QP VSS VSS nfet_03v3 w=4u l=0.28u m=1
XSP QP XP VDD VDD pfet_03v3 w=8u l=0.28u m=4
XSN QN XN VDD VDD pfet_03v3 w=8u l=0.28u m=4

* Cross-connected output inverters preserve decision polarity in one stage:
* QN low produces OUTP high and QP low produces OUTN high.
XOPP OUTP QN VDD VDD pfet_03v3 w=8u l=0.28u m=3
XOPN OUTP QN VSS VSS nfet_03v3 w=8u l=0.28u m=1
XONP OUTN QP VDD VDD pfet_03v3 w=8u l=0.28u m=3
XONN OUTN QP VSS VSS nfet_03v3 w=8u l=0.28u m=1
.ends cml_to_cmos
