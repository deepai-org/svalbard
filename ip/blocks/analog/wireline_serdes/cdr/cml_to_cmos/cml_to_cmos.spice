* SPDX-License-Identifier: Apache-2.0
* Clocked regenerative differential CML-to-CMOS sense amplifier.
.subckt cml_to_cmos INP INN SENSE_CLK REGEN_CLK REGEN_CLKB CAPTURE_CLK CAPTURE_CLKB VDD VSS OUTP OUTN SENSE_BOOST_CLK
* A small first stage acquires the CML decision on SA/SB.  These nodes only
* drive gates in the regenerative stage, isolating input sensing from the
* larger reset and positive-feedback diffusion capacitance on XP/XN.
XPREP SA SENSE_CLK VDD VDD pfet_03v3 w=8u l=0.28u m=2
XPREN SB SENSE_CLK VDD VDD pfet_03v3 w=8u l=0.28u m=2
XEQUAL SA SENSE_CLK SB VDD pfet_03v3 w=8u l=0.28u m=2
XALOADP SA VSS VDD VDD pfet_03v3 w=8u l=0.28u m=1
XALOADN SB VSS VDD VDD pfet_03v3 w=8u l=0.28u m=1

* XP/XN have a separate, regeneration-clocked reset.  It remains active
* throughout acquisition and releases only when the second stage evaluates.
XXPREP XP REGEN_CLK VDD VDD pfet_03v3 w=8u l=0.28u m=8
XXPREN XN REGEN_CLK VDD VDD pfet_03v3 w=8u l=0.28u m=8
XXEQUAL XP REGEN_CLK XN VDD pfet_03v3 w=8u l=0.28u m=8

* The complementary CDR clock disconnects PMOS regeneration throughout
* precharge, so the previous decision cannot fight XP/XN equalization.  The
* header and regeneration nodes are routed locally between adjacent rows.
XHP VREGP REGEN_CLKB VDD VDD pfet_03v3 w=8u l=0.28u m=8
XHN VREGN REGEN_CLKB VDD VDD pfet_03v3 w=8u l=0.28u m=8
XLATP XP XN VREGP VDD pfet_03v3 w=8u l=0.28u m=8
XLATN XN XP VREGN VDD pfet_03v3 w=8u l=0.28u m=8

* The input pair gets an acquisition interval before the separately phased
* second-stage input pair and cross-coupled devices enable regeneration.
XIP SA INP NTAIL VSS nfet_03v3 w=8u l=0.28u m=2
XIN SB INN NTAIL VSS nfet_03v3 w=8u l=0.28u m=2
XACQP XP SB NREGEN VSS nfet_03v3 w=8u l=0.28u m=8
XACQN XN SA NREGEN VSS nfet_03v3 w=8u l=0.28u m=8
XREGENP XP XN NREGEN VSS nfet_03v3 w=8u l=0.28u m=3
XREGENN XN XP NREGEN VSS nfet_03v3 w=8u l=0.28u m=3
XTAIL NTAIL SENSE_CLK VSS VSS nfet_03v3 w=8u l=0.28u m=2
XTAILBOOST NTAIL SENSE_BOOST_CLK VSS VSS nfet_03v3 w=8u l=0.28u m=6
XRTAIL NREGEN REGEN_CLK VSS VSS nfet_03v3 w=8u l=0.28u m=8
XRPREP NREGEN REGEN_CLK VDD VDD pfet_03v3 w=8u l=0.28u m=2
XRPREN NREGEN REGEN_CLK VDD VDD pfet_03v3 w=8u l=0.28u m=2

* Matched restoring inverters qualify the dynamic decision.  During precharge
* SXP=SXN=0; during evaluation only the side whose dynamic node resolves low
* can assert.  The following buffers preserve that decision for the aperture.
XBP SXP XP VDD VDD pfet_03v3 w=8u l=0.28u m=8
XBN SXP XP VSS VSS nfet_03v3 w=8u l=0.28u m=4
XDP SXN XN VDD VDD pfet_03v3 w=8u l=0.28u m=8
XDN SXN XN VSS VSS nfet_03v3 w=8u l=0.28u m=4

* Non-inverting two-stage output buffers expose the restored regenerative
* decision during its qualified aperture.  The clocked deserializer owns the
* sampling/hold function, avoiding a second static latch on these critical
* nodes.  CAPTURE_CLK/CLKB remain interface-compatible reserved pins.
XPBP BP SXP VDD VDD pfet_03v3 w=8u l=0.28u m=2
XPBN BP SXP VSS VSS nfet_03v3 w=8u l=0.28u m=8
XOPP OUTP BP VDD VDD pfet_03v3 w=8u l=0.28u m=8
XOPN OUTP BP VSS VSS nfet_03v3 w=8u l=0.28u m=6
XNBP BN SXN VDD VDD pfet_03v3 w=8u l=0.28u m=2
XNBN BN SXN VSS VSS nfet_03v3 w=8u l=0.28u m=8
XONP OUTN BN VDD VDD pfet_03v3 w=8u l=0.28u m=8
XONN OUTN BN VSS VSS nfet_03v3 w=8u l=0.28u m=6
.ends cml_to_cmos
