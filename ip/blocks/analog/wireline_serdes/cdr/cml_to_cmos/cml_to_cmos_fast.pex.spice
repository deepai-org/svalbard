* PEX produced using /foss/tools/sak/sak-pex.sh with m=3 and s=1 (extresist threshold=0 mOhm, minres=1 mOhm, mindelay=0 ps)
* NGSPICE file created from cml_to_cmos_pex.ext - technology: gf180mcuD

.subckt cml_to_cmos_pex INP INN SENSE_CLK REGEN_CLK REGEN_CLKB CAPTURE_CLK CAPTURE_CLKB
+ VDD VSS OUTP OUTN SENSE_BOOST_CLK
X0 VSS.t10 SENSE_CLK.t4 NTAIL.t0 VSS.t9 nfet_03v3 ad=2.6p pd=10.52u as=4.4p ps=20.88u w=10u l=0.28u
X1 DN.t0 XN.t48 VDD.t77 VDD.t76 pfet_03v3 ad=2.08p pd=8.52u as=2.08p ps=8.52u w=8u l=0.28u
X2 NTAIL.t32 SENSE_BOOST_CLK.t12 VSS.t131 VSS.t130 nfet_03v3 ad=2.6p pd=10.52u as=2.6p ps=10.52u w=10u l=0.28u
X3 VSS.t5 HB.t20 OUTN.t0 VSS.t4 nfet_03v3 ad=2.08p pd=8.52u as=3.52p ps=16.88u w=8u l=0.28u
X4 OUTN.t2 HB.t23 VDD.t95 VDD.t94 pfet_03v3 ad=2.08p pd=8.52u as=2.08p ps=8.52u w=8u l=0.28u
X5 VDD.t29 SENSE_CLK.t34 XP.t10 VDD.t28 pfet_03v3 ad=2.08p pd=8.52u as=2.08p ps=8.52u w=8u l=0.28u
X6 XP.t16 SENSE_CLK.t21 XN.t15 VDD.t49 pfet_03v3 ad=2.08p pd=8.52u as=2.08p ps=8.52u w=8u l=0.28u
X7 XN.t27 XP.t36 NIN.t23 VSS.t153 nfet_03v3 ad=2.08p pd=8.52u as=2.08p ps=8.52u w=8u l=0.28u
X8 NIP.t21 XN.t33 XP.t29 VSS.t103 nfet_03v3 ad=2.08p pd=8.52u as=2.08p ps=8.52u w=8u l=0.28u
X9 DN.t5 XN.t44 VSS.t82 VSS.t81 nfet_03v3 ad=3.52p pd=16.88u as=2.08p ps=8.52u w=8u l=0.28u
X10 VDD.t93 XN.t49 DN.t2 VDD.t92 pfet_03v3 ad=2.08p pd=8.52u as=3.52p ps=16.88u w=8u l=0.28u
X11 VDD.t101 HB.t24 OUTN.t4 VDD.t100 pfet_03v3 ad=2.08p pd=8.52u as=3.52p ps=16.88u w=8u l=0.28u
X12 NTAIL.t13 INP.t7 NIP.t9 VSS.t58 nfet_03v3 ad=2.08p pd=8.52u as=3.52p ps=16.88u w=8u l=0.28u
X13 XP.t11 SENSE_CLK.t33 VDD.t31 VDD.t30 pfet_03v3 ad=2.08p pd=8.52u as=2.08p ps=8.52u w=8u l=0.28u
X14 H.t3 HB.t25 VDD.t1 VDD.t0 pfet_03v3 ad=3.52p pd=16.88u as=2.08p ps=8.52u w=8u l=0.28u
X15 XP.t9 SENSE_CLK.t35 VDD.t27 VDD.t26 pfet_03v3 ad=2.08p pd=8.52u as=2.08p ps=8.52u w=8u l=0.28u
X16 NTAIL.t40 SENSE_BOOST_CLK.t4 VSS.t145 VSS.t144 nfet_03v3 ad=2.6p pd=10.52u as=2.6p ps=10.52u w=10u l=0.28u
X17 XP.t23 XN.t50 VDD.t107 VDD.t106 pfet_03v3 ad=3.52p pd=16.88u as=2.08p ps=8.52u w=8u l=0.28u
X18 VSS.t92 DN.t7 HB.t14 VSS.t91 nfet_03v3 ad=2.08p pd=8.52u as=2.08p ps=8.52u w=8u l=0.28u
X19 VDD.t71 SENSE_CLK.t12 XN.t2 VDD.t70 pfet_03v3 ad=2.08p pd=8.52u as=2.08p ps=8.52u w=8u l=0.28u
X20 VSS.t72 H.t19 OUTP.t3 VSS.t71 nfet_03v3 ad=2.08p pd=8.52u as=2.08p ps=8.52u w=8u l=0.28u
X21 VDD.t63 SENSE_CLK.t10 XN.t4 VDD.t62 pfet_03v3 ad=2.08p pd=8.52u as=2.08p ps=8.52u w=8u l=0.28u
X22 VDD.t3 H.t28 OUTP.t0 VDD.t2 pfet_03v3 ad=2.08p pd=8.52u as=3.52p ps=16.88u w=8u l=0.28u
X23 VSS.t149 SENSE_BOOST_CLK.t1 NTAIL.t43 VSS.t148 nfet_03v3 ad=2.6p pd=10.52u as=2.6p ps=10.52u w=10u l=0.28u
X24 NIP.t16 INP.t0 NTAIL.t15 VSS.t65 nfet_03v3 ad=3.52p pd=16.88u as=2.08p ps=8.52u w=8u l=0.28u
X25 VSS.t111 SENSE_BOOST_CLK.t23 NTAIL.t21 VSS.t110 nfet_03v3 ad=2.6p pd=10.52u as=4.4p ps=20.88u w=10u l=0.28u
X26 VDD.t125 XP.t53 HB.t6 VDD.t124 pfet_03v3 ad=2.08p pd=8.52u as=3.52p ps=16.88u w=8u l=0.28u
X27 NTAIL.t16 INP.t3 NIP.t13 VSS.t62 nfet_03v3 ad=2.08p pd=8.52u as=2.08p ps=8.52u w=8u l=0.28u
X28 HB.t13 DN.t8 VSS.t100 VSS.t99 nfet_03v3 ad=2.08p pd=8.52u as=2.08p ps=8.52u w=8u l=0.28u
X29 VDD.t21 SENSE_CLK.t40 XP.t4 VDD.t20 pfet_03v3 ad=2.08p pd=8.52u as=3.52p ps=16.88u w=8u l=0.28u
X30 NIP.t7 XN.t41 XP.t22 VSS.t34 nfet_03v3 ad=2.08p pd=8.52u as=2.08p ps=8.52u w=8u l=0.28u
X31 H.t16 DP.t6 VSS.t31 VSS.t30 nfet_03v3 ad=3.52p pd=16.88u as=2.08p ps=8.52u w=8u l=0.28u
X32 VDD.t37 SENSE_CLK.t30 NIP.t0 VDD.t36 pfet_03v3 ad=2.08p pd=8.52u as=3.52p ps=16.88u w=8u l=0.28u
X33 XN.t1 SENSE_CLK.t13 VDD.t13 VDD.t12 pfet_03v3 ad=2.08p pd=8.52u as=2.08p ps=8.52u w=8u l=0.28u
X34 OUTP.t4 H.t27 VDD.t119 VDD.t118 pfet_03v3 ad=2.08p pd=8.52u as=2.08p ps=8.52u w=8u l=0.28u
X35 NTAIL.t24 SENSE_BOOST_CLK.t20 VSS.t117 VSS.t116 nfet_03v3 ad=2.6p pd=10.52u as=2.6p ps=10.52u w=10u l=0.28u
X36 H.t5 XN.t54 VDD.t73 VDD.t72 pfet_03v3 ad=2.08p pd=8.52u as=2.08p ps=8.52u w=8u l=0.28u
X37 HB.t3 XP.t50 VDD.t105 VDD.t104 pfet_03v3 ad=3.52p pd=16.88u as=2.08p ps=8.52u w=8u l=0.28u
X38 XN.t12 SENSE_CLK.t24 XP.t1 VDD.t46 pfet_03v3 ad=2.08p pd=8.52u as=2.08p ps=8.52u w=8u l=0.28u
X39 XN.t9 SENSE_CLK.t5 VDD.t61 VDD.t60 pfet_03v3 ad=3.52p pd=16.88u as=2.08p ps=8.52u w=8u l=0.28u
X40 VSS.t140 SENSE_BOOST_CLK.t7 NTAIL.t37 VSS.t76 nfet_03v3 ad=2.6p pd=10.52u as=2.6p ps=10.52u w=10u l=0.28u
X41 NIP.t1 SENSE_CLK.t29 VDD.t39 VDD.t38 pfet_03v3 ad=2.08p pd=8.52u as=2.08p ps=8.52u w=8u l=0.28u
X42 NTAIL.t12 INN.t5 NIN.t11 VSS.t52 nfet_03v3 ad=2.08p pd=8.52u as=2.08p ps=8.52u w=8u l=0.28u
X43 VSS.t48 DP.t13 H.t9 VSS.t47 nfet_03v3 ad=2.08p pd=8.52u as=3.52p ps=16.88u w=8u l=0.28u
X44 XP.t15 SENSE_CLK.t23 XN.t13 VDD.t47 pfet_03v3 ad=2.08p pd=8.52u as=2.08p ps=8.52u w=8u l=0.28u
X45 NIN.t7 XP.t35 XN.t28 VSS.t39 nfet_03v3 ad=2.08p pd=8.52u as=2.08p ps=8.52u w=8u l=0.28u
X46 XP.t30 XN.t34 NIP.t22 VSS.t154 nfet_03v3 ad=2.08p pd=8.52u as=2.08p ps=8.52u w=8u l=0.28u
X47 NIN.t14 INN.t2 NTAIL.t11 VSS.t55 nfet_03v3 ad=2.08p pd=8.52u as=2.08p ps=8.52u w=8u l=0.28u
X48 VDD.t9 SENSE_CLK.t6 XN.t8 VDD.t8 pfet_03v3 ad=2.08p pd=8.52u as=2.08p ps=8.52u w=8u l=0.28u
X49 NTAIL.t1 SENSE_CLK.t3 VSS.t12 VSS.t11 nfet_03v3 ad=2.6p pd=10.52u as=2.6p ps=10.52u w=10u l=0.28u
X50 XN.t31 XP.t32 NIN.t17 VSS.t66 nfet_03v3 ad=3.52p pd=16.88u as=2.08p ps=8.52u w=8u l=0.28u
X51 NIP.t18 XN.t37 XP.t26 VSS.t73 nfet_03v3 ad=2.08p pd=8.52u as=2.08p ps=8.52u w=8u l=0.28u
X52 VDD.t57 SENSE_CLK.t16 NIN.t3 VDD.t56 pfet_03v3 ad=2.08p pd=8.52u as=2.08p ps=8.52u w=8u l=0.28u
X53 H.t10 DP.t12 VSS.t23 VSS.t22 nfet_03v3 ad=2.08p pd=8.52u as=2.08p ps=8.52u w=8u l=0.28u
X54 XN.t21 XP.t42 NIN.t19 VSS.t80 nfet_03v3 ad=2.08p pd=8.52u as=2.08p ps=8.52u w=8u l=0.28u
X55 DP.t0 XP.t46 VDD.t7 VDD.t6 pfet_03v3 ad=3.52p pd=16.88u as=2.08p ps=8.52u w=8u l=0.28u
X56 NIN.t0 XP.t39 XN.t24 VSS.t6 nfet_03v3 ad=2.08p pd=8.52u as=2.08p ps=8.52u w=8u l=0.28u
X57 DP.t3 XP.t44 VSS.t38 VSS.t37 nfet_03v3 ad=3.52p pd=16.88u as=2.08p ps=8.52u w=8u l=0.28u
X58 VDD.t129 XP.t55 XN.t18 VDD.t128 pfet_03v3 ad=2.08p pd=8.52u as=3.52p ps=16.88u w=8u l=0.28u
X59 VSS.t127 SENSE_BOOST_CLK.t15 NTAIL.t29 VSS.t126 nfet_03v3 ad=2.6p pd=10.52u as=2.6p ps=10.52u w=10u l=0.28u
X60 VSS.t77 XN.t45 DN.t4 VSS.t76 nfet_03v3 ad=2.08p pd=8.52u as=3.52p ps=16.88u w=8u l=0.28u
X61 NTAIL.t42 SENSE_BOOST_CLK.t2 VSS.t147 VSS.t146 nfet_03v3 ad=2.6p pd=10.52u as=2.6p ps=10.52u w=10u l=0.28u
X62 VDD.t33 SENSE_CLK.t32 XP.t12 VDD.t32 pfet_03v3 ad=2.08p pd=8.52u as=2.08p ps=8.52u w=8u l=0.28u
X63 NIN.t12 INN.t4 NTAIL.t5 VSS.t53 nfet_03v3 ad=2.08p pd=8.52u as=2.08p ps=8.52u w=8u l=0.28u
X64 VDD.t91 XN.t53 H.t8 VDD.t90 pfet_03v3 ad=2.08p pd=8.52u as=2.08p ps=8.52u w=8u l=0.28u
X65 VSS.t115 SENSE_BOOST_CLK.t21 NTAIL.t23 VSS.t114 nfet_03v3 ad=2.6p pd=10.52u as=2.6p ps=10.52u w=10u l=0.28u
X66 VDD.t5 XP.t51 HB.t0 VDD.t4 pfet_03v3 ad=2.08p pd=8.52u as=2.08p ps=8.52u w=8u l=0.28u
X67 NTAIL.t6 INN.t1 NIN.t15 VSS.t56 nfet_03v3 ad=2.08p pd=8.52u as=2.08p ps=8.52u w=8u l=0.28u
X68 XP.t24 XN.t38 NIP.t8 VSS.t49 nfet_03v3 ad=2.08p pd=8.52u as=2.08p ps=8.52u w=8u l=0.28u
X69 XP.t13 SENSE_CLK.t31 VDD.t35 VDD.t34 pfet_03v3 ad=3.52p pd=16.88u as=2.08p ps=8.52u w=8u l=0.28u
X70 NTAIL.t26 SENSE_BOOST_CLK.t18 VSS.t121 VSS.t120 nfet_03v3 ad=2.6p pd=10.52u as=2.6p ps=10.52u w=10u l=0.28u
X71 OUTN.t3 HB.t17 VSS.t36 VSS.t35 nfet_03v3 ad=3.52p pd=16.88u as=2.08p ps=8.52u w=8u l=0.28u
X72 OUTP.t2 H.t18 VSS.t70 VSS.t69 nfet_03v3 ad=3.52p pd=16.88u as=2.08p ps=8.52u w=8u l=0.28u
X73 VSS.t94 DN.t9 HB.t12 VSS.t93 nfet_03v3 ad=2.08p pd=8.52u as=2.08p ps=8.52u w=8u l=0.28u
X74 XP.t5 SENSE_CLK.t39 VDD.t17 VDD.t16 pfet_03v3 ad=2.08p pd=8.52u as=2.08p ps=8.52u w=8u l=0.28u
X75 XN.t25 XP.t38 NIN.t21 VSS.t84 nfet_03v3 ad=2.08p pd=8.52u as=2.08p ps=8.52u w=8u l=0.28u
X76 VSS.t75 HB.t21 H.t4 VSS.t74 nfet_03v3 ad=3.52p pd=16.88u as=3.52p ps=16.88u w=8u l=0.28u
X77 VDD.t69 SENSE_CLK.t14 XN.t0 VDD.t68 pfet_03v3 ad=2.08p pd=8.52u as=3.52p ps=16.88u w=8u l=0.28u
X78 VDD.t103 H.t26 OUTP.t1 VDD.t102 pfet_03v3 ad=3.52p pd=16.88u as=2.08p ps=8.52u w=8u l=0.28u
X79 VDD.t19 SENSE_CLK.t38 XP.t6 VDD.t18 pfet_03v3 ad=2.08p pd=8.52u as=2.08p ps=8.52u w=8u l=0.28u
X80 VSS.t105 H.t17 HB.t7 VSS.t104 nfet_03v3 ad=3.52p pd=16.88u as=3.52p ps=16.88u w=8u l=0.28u
X81 VDD.t41 SENSE_CLK.t28 NIP.t2 VDD.t40 pfet_03v3 ad=2.08p pd=8.52u as=2.08p ps=8.52u w=8u l=0.28u
X82 NTAIL.t34 SENSE_BOOST_CLK.t10 VSS.t135 VSS.t134 nfet_03v3 ad=2.6p pd=10.52u as=2.6p ps=10.52u w=10u l=0.28u
X83 XN.t7 SENSE_CLK.t7 VDD.t65 VDD.t64 pfet_03v3 ad=2.08p pd=8.52u as=2.08p ps=8.52u w=8u l=0.28u
X84 H.t1 HB.t27 VDD.t127 VDD.t126 pfet_03v3 ad=2.08p pd=8.52u as=2.08p ps=8.52u w=8u l=0.28u
X85 NIN.t2 SENSE_CLK.t17 VDD.t55 VDD.t54 pfet_03v3 ad=2.08p pd=8.52u as=2.08p ps=8.52u w=8u l=0.28u
X86 VSS.t8 SENSE_CLK.t0 NTAIL.t4 VSS.t7 nfet_03v3 ad=4.4p pd=20.88u as=2.6p ps=10.52u w=10u l=0.28u
X87 VSS.t21 DP.t11 H.t11 VSS.t20 nfet_03v3 ad=2.08p pd=8.52u as=2.08p ps=8.52u w=8u l=0.28u
X88 VSS.t19 DP.t9 H.t13 VSS.t18 nfet_03v3 ad=2.08p pd=8.52u as=2.08p ps=8.52u w=8u l=0.28u
X89 NTAIL.t28 SENSE_BOOST_CLK.t16 VSS.t125 VSS.t124 nfet_03v3 ad=2.6p pd=10.52u as=2.6p ps=10.52u w=10u l=0.28u
X90 VDD.t11 SENSE_CLK.t8 XN.t6 VDD.t10 pfet_03v3 ad=2.08p pd=8.52u as=2.08p ps=8.52u w=8u l=0.28u
X91 VDD.t113 H.t23 HB.t4 VDD.t112 pfet_03v3 ad=2.08p pd=8.52u as=2.08p ps=8.52u w=8u l=0.28u
X92 VDD.t53 SENSE_CLK.t18 NIN.t1 VDD.t52 pfet_03v3 ad=2.08p pd=8.52u as=3.52p ps=16.88u w=8u l=0.28u
X93 NIN.t16 INN.t0 NTAIL.t10 VSS.t57 nfet_03v3 ad=3.52p pd=16.88u as=2.08p ps=8.52u w=8u l=0.28u
X94 NTAIL.t18 INP.t1 NIP.t15 VSS.t64 nfet_03v3 ad=2.08p pd=8.52u as=2.08p ps=8.52u w=8u l=0.28u
X95 NIP.t5 XN.t39 XP.t20 VSS.t26 nfet_03v3 ad=2.08p pd=8.52u as=2.08p ps=8.52u w=8u l=0.28u
X96 H.t12 DP.t10 VSS.t33 VSS.t32 nfet_03v3 ad=2.08p pd=8.52u as=2.08p ps=8.52u w=8u l=0.28u
X97 VSS.t129 SENSE_BOOST_CLK.t13 NTAIL.t31 VSS.t128 nfet_03v3 ad=2.6p pd=10.52u as=2.6p ps=10.52u w=10u l=0.28u
X98 NIP.t12 INP.t4 NTAIL.t20 VSS.t61 nfet_03v3 ad=2.08p pd=8.52u as=2.08p ps=8.52u w=8u l=0.28u
X99 XP.t27 XN.t42 NIP.t19 VSS.t89 nfet_03v3 ad=2.08p pd=8.52u as=2.08p ps=8.52u w=8u l=0.28u
X100 HB.t11 DN.t10 VSS.t102 VSS.t101 nfet_03v3 ad=2.08p pd=8.52u as=2.08p ps=8.52u w=8u l=0.28u
X101 H.t6 XN.t52 VDD.t75 VDD.t74 pfet_03v3 ad=3.52p pd=16.88u as=2.08p ps=8.52u w=8u l=0.28u
X102 NTAIL.t22 SENSE_BOOST_CLK.t22 VSS.t113 VSS.t112 nfet_03v3 ad=2.6p pd=10.52u as=2.6p ps=10.52u w=10u l=0.28u
X103 HB.t5 XP.t52 VDD.t121 VDD.t120 pfet_03v3 ad=2.08p pd=8.52u as=2.08p ps=8.52u w=8u l=0.28u
X104 HB.t16 H.t22 VDD.t131 VDD.t130 pfet_03v3 ad=3.52p pd=16.88u as=2.08p ps=8.52u w=8u l=0.28u
X105 NIN.t8 XP.t37 XN.t26 VSS.t46 nfet_03v3 ad=2.08p pd=8.52u as=2.08p ps=8.52u w=8u l=0.28u
X106 NTAIL.t8 INN.t7 NIN.t9 VSS.t50 nfet_03v3 ad=2.08p pd=8.52u as=3.52p ps=16.88u w=8u l=0.28u
X107 XP.t21 XN.t32 NIP.t6 VSS.t27 nfet_03v3 ad=3.52p pd=16.88u as=2.08p ps=8.52u w=8u l=0.28u
X108 VSS.t96 DN.t11 HB.t10 VSS.t95 nfet_03v3 ad=2.08p pd=8.52u as=2.08p ps=8.52u w=8u l=0.28u
X109 VDD.t89 XN.t55 H.t7 VDD.t88 pfet_03v3 ad=2.08p pd=8.52u as=3.52p ps=16.88u w=8u l=0.28u
X110 VSS.t109 SENSE_BOOST_CLK.t19 NTAIL.t25 VSS.t108 nfet_03v3 ad=2.6p pd=10.52u as=2.6p ps=10.52u w=10u l=0.28u
X111 XN.t29 XP.t34 NIN.t6 VSS.t25 nfet_03v3 ad=2.08p pd=8.52u as=2.08p ps=8.52u w=8u l=0.28u
X112 NIP.t23 XN.t35 XP.t31 VSS.t155 nfet_03v3 ad=2.08p pd=8.52u as=2.08p ps=8.52u w=8u l=0.28u
X113 VSS.t143 SENSE_BOOST_CLK.t5 NTAIL.t39 VSS.t142 nfet_03v3 ad=2.6p pd=10.52u as=2.6p ps=10.52u w=10u l=0.28u
X114 NIN.t22 XP.t41 XN.t22 VSS.t152 nfet_03v3 ad=2.08p pd=8.52u as=2.08p ps=8.52u w=8u l=0.28u
X115 DP.t1 XP.t48 VDD.t83 VDD.t82 pfet_03v3 ad=2.08p pd=8.52u as=2.08p ps=8.52u w=8u l=0.28u
X116 VSS.t133 SENSE_BOOST_CLK.t11 NTAIL.t33 VSS.t132 nfet_03v3 ad=2.6p pd=10.52u as=2.6p ps=10.52u w=10u l=0.28u
X117 VSS.t41 HB.t18 OUTN.t5 VSS.t40 nfet_03v3 ad=2.08p pd=8.52u as=2.08p ps=8.52u w=8u l=0.28u
X118 XP.t14 SENSE_CLK.t19 XN.t17 VDD.t51 pfet_03v3 ad=3.52p pd=16.88u as=2.08p ps=8.52u w=8u l=0.28u
X119 NIP.t14 INP.t2 NTAIL.t17 VSS.t63 nfet_03v3 ad=2.08p pd=8.52u as=2.08p ps=8.52u w=8u l=0.28u
X120 VDD.t87 XN.t47 DN.t1 VDD.t86 pfet_03v3 ad=2.08p pd=8.52u as=2.08p ps=8.52u w=8u l=0.28u
X121 NTAIL.t36 SENSE_BOOST_CLK.t8 VSS.t137 VSS.t136 nfet_03v3 ad=2.6p pd=10.52u as=2.6p ps=10.52u w=10u l=0.28u
X122 NTAIL.t19 INP.t5 NIP.t11 VSS.t60 nfet_03v3 ad=2.08p pd=8.52u as=2.08p ps=8.52u w=8u l=0.28u
X123 VDD.t79 HB.t22 OUTN.t1 VDD.t78 pfet_03v3 ad=3.52p pd=16.88u as=2.08p ps=8.52u w=8u l=0.28u
X124 VSS.t123 SENSE_BOOST_CLK.t17 NTAIL.t27 VSS.t122 nfet_03v3 ad=2.6p pd=10.52u as=2.6p ps=10.52u w=10u l=0.28u
X125 XP.t7 SENSE_CLK.t37 VDD.t23 VDD.t22 pfet_03v3 ad=2.08p pd=8.52u as=2.08p ps=8.52u w=8u l=0.28u
X126 VSS.t14 SENSE_CLK.t2 NTAIL.t2 VSS.t13 nfet_03v3 ad=2.6p pd=10.52u as=2.6p ps=10.52u w=10u l=0.28u
X127 NIP.t3 SENSE_CLK.t27 VDD.t43 VDD.t42 pfet_03v3 ad=3.52p pd=16.88u as=2.08p ps=8.52u w=8u l=0.28u
X128 DN.t3 XN.t46 VDD.t109 VDD.t108 pfet_03v3 ad=3.52p pd=16.88u as=2.08p ps=8.52u w=8u l=0.28u
X129 NIN.t10 INN.t6 NTAIL.t9 VSS.t51 nfet_03v3 ad=2.08p pd=8.52u as=2.08p ps=8.52u w=8u l=0.28u
X130 VDD.t85 XN.t51 XP.t19 VDD.t84 pfet_03v3 ad=2.08p pd=8.52u as=3.52p ps=16.88u w=8u l=0.28u
X131 NTAIL.t30 SENSE_BOOST_CLK.t14 VSS.t107 VSS.t106 nfet_03v3 ad=2.6p pd=10.52u as=2.6p ps=10.52u w=10u l=0.28u
X132 VSS.t88 H.t21 OUTP.t6 VSS.t87 nfet_03v3 ad=2.08p pd=8.52u as=3.52p ps=16.88u w=8u l=0.28u
X133 NTAIL.t7 INN.t3 NIN.t13 VSS.t54 nfet_03v3 ad=2.08p pd=8.52u as=2.08p ps=8.52u w=8u l=0.28u
X134 XP.t28 XN.t36 NIP.t20 VSS.t90 nfet_03v3 ad=2.08p pd=8.52u as=2.08p ps=8.52u w=8u l=0.28u
X135 VDD.t123 HB.t26 H.t2 VDD.t122 pfet_03v3 ad=2.08p pd=8.52u as=2.08p ps=8.52u w=8u l=0.28u
X136 NIN.t18 XP.t33 XN.t30 VSS.t67 nfet_03v3 ad=2.08p pd=8.52u as=2.08p ps=8.52u w=8u l=0.28u
X137 VDD.t25 SENSE_CLK.t36 XP.t8 VDD.t24 pfet_03v3 ad=2.08p pd=8.52u as=2.08p ps=8.52u w=8u l=0.28u
X138 VDD.t115 HB.t28 H.t0 VDD.t114 pfet_03v3 ad=2.08p pd=8.52u as=3.52p ps=16.88u w=8u l=0.28u
X139 HB.t15 DN.t6 VSS.t79 VSS.t78 nfet_03v3 ad=3.52p pd=16.88u as=2.08p ps=8.52u w=8u l=0.28u
X140 H.t14 DP.t8 VSS.t1 VSS.t0 nfet_03v3 ad=2.08p pd=8.52u as=2.08p ps=8.52u w=8u l=0.28u
X141 XN.t3 SENSE_CLK.t11 VDD.t67 VDD.t66 pfet_03v3 ad=2.08p pd=8.52u as=2.08p ps=8.52u w=8u l=0.28u
X142 OUTP.t5 H.t20 VSS.t86 VSS.t85 nfet_03v3 ad=2.08p pd=8.52u as=2.08p ps=8.52u w=8u l=0.28u
X143 XN.t5 SENSE_CLK.t9 VDD.t59 VDD.t58 pfet_03v3 ad=2.08p pd=8.52u as=2.08p ps=8.52u w=8u l=0.28u
X144 HB.t1 H.t24 VDD.t81 VDD.t80 pfet_03v3 ad=2.08p pd=8.52u as=2.08p ps=8.52u w=8u l=0.28u
X145 NIN.t5 XP.t43 XN.t20 VSS.t24 nfet_03v3 ad=2.08p pd=8.52u as=3.52p ps=16.88u w=8u l=0.28u
X146 XN.t10 SENSE_CLK.t26 XP.t2 VDD.t44 pfet_03v3 ad=2.08p pd=8.52u as=3.52p ps=16.88u w=8u l=0.28u
X147 XN.t23 XP.t40 NIN.t20 VSS.t83 nfet_03v3 ad=2.08p pd=8.52u as=2.08p ps=8.52u w=8u l=0.28u
X148 VSS.t3 DP.t7 H.t15 VSS.t2 nfet_03v3 ad=2.08p pd=8.52u as=2.08p ps=8.52u w=8u l=0.28u
X149 VDD.t97 H.t25 HB.t2 VDD.t96 pfet_03v3 ad=2.08p pd=8.52u as=3.52p ps=16.88u w=8u l=0.28u
X150 XP.t3 SENSE_CLK.t25 XN.t11 VDD.t45 pfet_03v3 ad=2.08p pd=8.52u as=2.08p ps=8.52u w=8u l=0.28u
X151 VSS.t119 SENSE_BOOST_CLK.t3 NTAIL.t41 VSS.t118 nfet_03v3 ad=2.6p pd=10.52u as=2.6p ps=10.52u w=10u l=0.28u
X152 HB.t9 DN.t12 VSS.t98 VSS.t97 nfet_03v3 ad=2.08p pd=8.52u as=2.08p ps=8.52u w=8u l=0.28u
X153 NIP.t10 INP.t6 NTAIL.t14 VSS.t59 nfet_03v3 ad=2.08p pd=8.52u as=2.08p ps=8.52u w=8u l=0.28u
X154 NTAIL.t44 SENSE_BOOST_CLK.t0 VSS.t151 VSS.t150 nfet_03v3 ad=4.4p pd=20.88u as=2.6p ps=10.52u w=10u l=0.28u
X155 NIN.t4 SENSE_CLK.t15 VDD.t15 VDD.t14 pfet_03v3 ad=3.52p pd=16.88u as=2.08p ps=8.52u w=8u l=0.28u
X156 VSS.t139 SENSE_BOOST_CLK.t9 NTAIL.t35 VSS.t138 nfet_03v3 ad=2.6p pd=10.52u as=2.6p ps=10.52u w=10u l=0.28u
X157 VSS.t29 DN.t13 HB.t8 VSS.t28 nfet_03v3 ad=2.08p pd=8.52u as=3.52p ps=16.88u w=8u l=0.28u
X158 NTAIL.t38 SENSE_BOOST_CLK.t6 VSS.t141 VSS.t81 nfet_03v3 ad=2.6p pd=10.52u as=2.6p ps=10.52u w=10u l=0.28u
X159 VDD.t117 XP.t47 DP.t5 VDD.t116 pfet_03v3 ad=2.08p pd=8.52u as=2.08p ps=8.52u w=8u l=0.28u
X160 NTAIL.t3 SENSE_CLK.t1 VSS.t16 VSS.t15 nfet_03v3 ad=2.6p pd=10.52u as=2.6p ps=10.52u w=10u l=0.28u
X161 XP.t18 XN.t40 NIP.t4 VSS.t17 nfet_03v3 ad=2.08p pd=8.52u as=2.08p ps=8.52u w=8u l=0.28u
X162 OUTN.t6 HB.t19 VSS.t43 VSS.t42 nfet_03v3 ad=2.08p pd=8.52u as=2.08p ps=8.52u w=8u l=0.28u
X163 XN.t14 SENSE_CLK.t22 XP.t0 VDD.t48 pfet_03v3 ad=2.08p pd=8.52u as=2.08p ps=8.52u w=8u l=0.28u
X164 VDD.t99 XP.t49 DP.t2 VDD.t98 pfet_03v3 ad=2.08p pd=8.52u as=3.52p ps=16.88u w=8u l=0.28u
X165 XN.t19 XP.t54 VDD.t111 VDD.t110 pfet_03v3 ad=3.52p pd=16.88u as=2.08p ps=8.52u w=8u l=0.28u
X166 XN.t16 SENSE_CLK.t20 XP.t17 VDD.t50 pfet_03v3 ad=2.08p pd=8.52u as=2.08p ps=8.52u w=8u l=0.28u
X167 NIP.t17 XN.t43 XP.t25 VSS.t68 nfet_03v3 ad=2.08p pd=8.52u as=3.52p ps=16.88u w=8u l=0.28u
X168 VSS.t45 XP.t45 DP.t4 VSS.t44 nfet_03v3 ad=2.08p pd=8.52u as=3.52p ps=16.88u w=8u l=0.28u
R0 SENSE_BOOST_CLK.t23 SENSE_BOOST_CLK.n52 153.859
R1 SENSE_BOOST_CLK.t0 SENSE_BOOST_CLK.n23 153.859
R2 SENSE_BOOST_CLK.t13 SENSE_BOOST_CLK.n38 153.739
R3 SENSE_BOOST_CLK.t15 SENSE_BOOST_CLK.n62 153.739
R4 SENSE_BOOST_CLK.n61 SENSE_BOOST_CLK.t16 153.739
R5 SENSE_BOOST_CLK.n52 SENSE_BOOST_CLK.t22 153.739
R6 SENSE_BOOST_CLK.n51 SENSE_BOOST_CLK.t21 153.739
R7 SENSE_BOOST_CLK.n50 SENSE_BOOST_CLK.t20 153.739
R8 SENSE_BOOST_CLK.n49 SENSE_BOOST_CLK.t19 153.739
R9 SENSE_BOOST_CLK.t18 SENSE_BOOST_CLK.n43 153.739
R10 SENSE_BOOST_CLK.n60 SENSE_BOOST_CLK.t17 153.739
R11 SENSE_BOOST_CLK.t14 SENSE_BOOST_CLK.n0 153.739
R12 SENSE_BOOST_CLK.n23 SENSE_BOOST_CLK.t1 153.739
R13 SENSE_BOOST_CLK.n22 SENSE_BOOST_CLK.t2 153.739
R14 SENSE_BOOST_CLK.n21 SENSE_BOOST_CLK.t3 153.739
R15 SENSE_BOOST_CLK.n20 SENSE_BOOST_CLK.t4 153.739
R16 SENSE_BOOST_CLK.n19 SENSE_BOOST_CLK.t5 153.739
R17 SENSE_BOOST_CLK.n18 SENSE_BOOST_CLK.t6 153.739
R18 SENSE_BOOST_CLK.n17 SENSE_BOOST_CLK.t7 153.739
R19 SENSE_BOOST_CLK.n16 SENSE_BOOST_CLK.t8 153.739
R20 SENSE_BOOST_CLK.n15 SENSE_BOOST_CLK.t9 153.739
R21 SENSE_BOOST_CLK.t10 SENSE_BOOST_CLK.n3 153.739
R22 SENSE_BOOST_CLK.n36 SENSE_BOOST_CLK.t11 153.739
R23 SENSE_BOOST_CLK.n37 SENSE_BOOST_CLK.t12 153.739
R24 SENSE_BOOST_CLK.n53 SENSE_BOOST_CLK.t23 139.702
R25 SENSE_BOOST_CLK.n24 SENSE_BOOST_CLK.t0 139.702
R26 SENSE_BOOST_CLK.n39 SENSE_BOOST_CLK.t13 135.246
R27 SENSE_BOOST_CLK.n63 SENSE_BOOST_CLK.t15 135.246
R28 SENSE_BOOST_CLK.t16 SENSE_BOOST_CLK.n42 135.246
R29 SENSE_BOOST_CLK.n54 SENSE_BOOST_CLK.t22 135.246
R30 SENSE_BOOST_CLK.n55 SENSE_BOOST_CLK.t21 135.246
R31 SENSE_BOOST_CLK.n56 SENSE_BOOST_CLK.t20 135.246
R32 SENSE_BOOST_CLK.n57 SENSE_BOOST_CLK.t19 135.246
R33 SENSE_BOOST_CLK.n58 SENSE_BOOST_CLK.t18 135.246
R34 SENSE_BOOST_CLK.t17 SENSE_BOOST_CLK.n59 135.246
R35 SENSE_BOOST_CLK.n40 SENSE_BOOST_CLK.t14 135.246
R36 SENSE_BOOST_CLK.n25 SENSE_BOOST_CLK.t1 135.246
R37 SENSE_BOOST_CLK.n26 SENSE_BOOST_CLK.t2 135.246
R38 SENSE_BOOST_CLK.n27 SENSE_BOOST_CLK.t3 135.246
R39 SENSE_BOOST_CLK.n28 SENSE_BOOST_CLK.t4 135.246
R40 SENSE_BOOST_CLK.n29 SENSE_BOOST_CLK.t5 135.246
R41 SENSE_BOOST_CLK.n30 SENSE_BOOST_CLK.t6 135.246
R42 SENSE_BOOST_CLK.n31 SENSE_BOOST_CLK.t7 135.246
R43 SENSE_BOOST_CLK.n32 SENSE_BOOST_CLK.t8 135.246
R44 SENSE_BOOST_CLK.n33 SENSE_BOOST_CLK.t9 135.246
R45 SENSE_BOOST_CLK.n34 SENSE_BOOST_CLK.t10 135.246
R46 SENSE_BOOST_CLK.t11 SENSE_BOOST_CLK.n35 135.246
R47 SENSE_BOOST_CLK.t12 SENSE_BOOST_CLK.n2 135.246
R48 SENSE_BOOST_CLK SENSE_BOOST_CLK.n66 31.5205
R49 SENSE_BOOST_CLK.n39 SENSE_BOOST_CLK.n1 18.4942
R50 SENSE_BOOST_CLK.n64 SENSE_BOOST_CLK.n63 18.4942
R51 SENSE_BOOST_CLK.n42 SENSE_BOOST_CLK.n41 18.4942
R52 SENSE_BOOST_CLK.n55 SENSE_BOOST_CLK.n48 18.4942
R53 SENSE_BOOST_CLK.n56 SENSE_BOOST_CLK.n47 18.4942
R54 SENSE_BOOST_CLK.n57 SENSE_BOOST_CLK.n46 18.4942
R55 SENSE_BOOST_CLK.n58 SENSE_BOOST_CLK.n45 18.4942
R56 SENSE_BOOST_CLK.n59 SENSE_BOOST_CLK.n44 18.4942
R57 SENSE_BOOST_CLK.n65 SENSE_BOOST_CLK.n40 18.4942
R58 SENSE_BOOST_CLK.n26 SENSE_BOOST_CLK.n14 18.4942
R59 SENSE_BOOST_CLK.n27 SENSE_BOOST_CLK.n13 18.4942
R60 SENSE_BOOST_CLK.n28 SENSE_BOOST_CLK.n12 18.4942
R61 SENSE_BOOST_CLK.n29 SENSE_BOOST_CLK.n11 18.4942
R62 SENSE_BOOST_CLK.n30 SENSE_BOOST_CLK.n10 18.4942
R63 SENSE_BOOST_CLK.n31 SENSE_BOOST_CLK.n9 18.4942
R64 SENSE_BOOST_CLK.n32 SENSE_BOOST_CLK.n8 18.4942
R65 SENSE_BOOST_CLK.n33 SENSE_BOOST_CLK.n7 18.4942
R66 SENSE_BOOST_CLK.n34 SENSE_BOOST_CLK.n6 18.4942
R67 SENSE_BOOST_CLK.n35 SENSE_BOOST_CLK.n5 18.4942
R68 SENSE_BOOST_CLK.n4 SENSE_BOOST_CLK.n2 18.4942
R69 SENSE_BOOST_CLK.n63 SENSE_BOOST_CLK.n40 11.6805
R70 SENSE_BOOST_CLK.n63 SENSE_BOOST_CLK.n42 11.6805
R71 SENSE_BOOST_CLK.n55 SENSE_BOOST_CLK.n54 11.6805
R72 SENSE_BOOST_CLK.n56 SENSE_BOOST_CLK.n55 11.6805
R73 SENSE_BOOST_CLK.n57 SENSE_BOOST_CLK.n56 11.6805
R74 SENSE_BOOST_CLK.n58 SENSE_BOOST_CLK.n57 11.6805
R75 SENSE_BOOST_CLK.n59 SENSE_BOOST_CLK.n58 11.6805
R76 SENSE_BOOST_CLK.n59 SENSE_BOOST_CLK.n42 11.6805
R77 SENSE_BOOST_CLK.n40 SENSE_BOOST_CLK.n39 11.6805
R78 SENSE_BOOST_CLK.n26 SENSE_BOOST_CLK.n25 11.6805
R79 SENSE_BOOST_CLK.n27 SENSE_BOOST_CLK.n26 11.6805
R80 SENSE_BOOST_CLK.n28 SENSE_BOOST_CLK.n27 11.6805
R81 SENSE_BOOST_CLK.n29 SENSE_BOOST_CLK.n28 11.6805
R82 SENSE_BOOST_CLK.n30 SENSE_BOOST_CLK.n29 11.6805
R83 SENSE_BOOST_CLK.n31 SENSE_BOOST_CLK.n30 11.6805
R84 SENSE_BOOST_CLK.n32 SENSE_BOOST_CLK.n31 11.6805
R85 SENSE_BOOST_CLK.n33 SENSE_BOOST_CLK.n32 11.6805
R86 SENSE_BOOST_CLK.n34 SENSE_BOOST_CLK.n33 11.6805
R87 SENSE_BOOST_CLK.n35 SENSE_BOOST_CLK.n34 11.6805
R88 SENSE_BOOST_CLK.n35 SENSE_BOOST_CLK.n2 11.6805
R89 SENSE_BOOST_CLK.n39 SENSE_BOOST_CLK.n2 11.6805
R90 SENSE_BOOST_CLK.n66 SENSE_BOOST_CLK.n65 10.3505
R91 SENSE_BOOST_CLK.n66 SENSE_BOOST_CLK.n0 9.88093
R92 SENSE_BOOST_CLK.n53 SENSE_BOOST_CLK.n48 7.17687
R93 SENSE_BOOST_CLK.n24 SENSE_BOOST_CLK.n14 7.17687
R94 SENSE_BOOST_CLK.n54 SENSE_BOOST_CLK.n53 4.42851
R95 SENSE_BOOST_CLK.n25 SENSE_BOOST_CLK.n24 4.42851
R96 SENSE_BOOST_CLK.n4 SENSE_BOOST_CLK.n1 0.1205
R97 SENSE_BOOST_CLK.n5 SENSE_BOOST_CLK.n4 0.1205
R98 SENSE_BOOST_CLK.n6 SENSE_BOOST_CLK.n5 0.1205
R99 SENSE_BOOST_CLK.n7 SENSE_BOOST_CLK.n6 0.1205
R100 SENSE_BOOST_CLK.n8 SENSE_BOOST_CLK.n7 0.1205
R101 SENSE_BOOST_CLK.n9 SENSE_BOOST_CLK.n8 0.1205
R102 SENSE_BOOST_CLK.n10 SENSE_BOOST_CLK.n9 0.1205
R103 SENSE_BOOST_CLK.n11 SENSE_BOOST_CLK.n10 0.1205
R104 SENSE_BOOST_CLK.n12 SENSE_BOOST_CLK.n11 0.1205
R105 SENSE_BOOST_CLK.n13 SENSE_BOOST_CLK.n12 0.1205
R106 SENSE_BOOST_CLK.n14 SENSE_BOOST_CLK.n13 0.1205
R107 SENSE_BOOST_CLK.n38 SENSE_BOOST_CLK.n37 0.1205
R108 SENSE_BOOST_CLK.n37 SENSE_BOOST_CLK.n36 0.1205
R109 SENSE_BOOST_CLK.n36 SENSE_BOOST_CLK.n3 0.1205
R110 SENSE_BOOST_CLK.n15 SENSE_BOOST_CLK.n3 0.1205
R111 SENSE_BOOST_CLK.n16 SENSE_BOOST_CLK.n15 0.1205
R112 SENSE_BOOST_CLK.n17 SENSE_BOOST_CLK.n16 0.1205
R113 SENSE_BOOST_CLK.n18 SENSE_BOOST_CLK.n17 0.1205
R114 SENSE_BOOST_CLK.n19 SENSE_BOOST_CLK.n18 0.1205
R115 SENSE_BOOST_CLK.n20 SENSE_BOOST_CLK.n19 0.1205
R116 SENSE_BOOST_CLK.n21 SENSE_BOOST_CLK.n20 0.1205
R117 SENSE_BOOST_CLK.n22 SENSE_BOOST_CLK.n21 0.1205
R118 SENSE_BOOST_CLK.n23 SENSE_BOOST_CLK.n22 0.1205
R119 SENSE_BOOST_CLK.n52 SENSE_BOOST_CLK.n51 0.1205
R120 SENSE_BOOST_CLK.n51 SENSE_BOOST_CLK.n50 0.1205
R121 SENSE_BOOST_CLK.n50 SENSE_BOOST_CLK.n49 0.1205
R122 SENSE_BOOST_CLK.n49 SENSE_BOOST_CLK.n43 0.1205
R123 SENSE_BOOST_CLK.n60 SENSE_BOOST_CLK.n43 0.1205
R124 SENSE_BOOST_CLK.n61 SENSE_BOOST_CLK.n60 0.1205
R125 SENSE_BOOST_CLK.n62 SENSE_BOOST_CLK.n61 0.1205
R126 SENSE_BOOST_CLK.n48 SENSE_BOOST_CLK.n47 0.1205
R127 SENSE_BOOST_CLK.n47 SENSE_BOOST_CLK.n46 0.1205
R128 SENSE_BOOST_CLK.n46 SENSE_BOOST_CLK.n45 0.1205
R129 SENSE_BOOST_CLK.n45 SENSE_BOOST_CLK.n44 0.1205
R130 SENSE_BOOST_CLK.n44 SENSE_BOOST_CLK.n41 0.1205
R131 SENSE_BOOST_CLK.n64 SENSE_BOOST_CLK.n41 0.1205
R132 SENSE_BOOST_CLK.n65 SENSE_BOOST_CLK.n1 0.1085
R133 SENSE_BOOST_CLK.n38 SENSE_BOOST_CLK.n0 0.1085
R134 SENSE_BOOST_CLK.n62 SENSE_BOOST_CLK.n0 0.1085
R135 SENSE_BOOST_CLK.n65 SENSE_BOOST_CLK.n64 0.1085
R136 INN.t0 INN.n7 127.788
R137 INN.t7 INN.n0 127.776
R138 INN.t5 INN.n14 127.668
R139 INN.t6 INN.n0 127.668
R140 INN.n7 INN.t1 127.668
R141 INN.t2 INN.n3 127.668
R142 INN.n12 INN.t3 127.668
R143 INN.n13 INN.t4 127.668
R144 INN.n8 INN.t0 113.632
R145 INN.n17 INN.t7 113.629
R146 INN.n15 INN.t5 109.174
R147 INN.n16 INN.t6 109.174
R148 INN.n9 INN.t1 109.174
R149 INN.n10 INN.t2 109.174
R150 INN.t3 INN.n11 109.174
R151 INN.t4 INN.n2 109.174
R152 INN INN.n19 31.3053
R153 INN.n15 INN.n1 18.4942
R154 INN.n10 INN.n6 18.4942
R155 INN.n11 INN.n5 18.4942
R156 INN.n4 INN.n2 18.4942
R157 INN.n16 INN.n15 11.6805
R158 INN.n10 INN.n9 11.6805
R159 INN.n11 INN.n10 11.6805
R160 INN.n11 INN.n2 11.6805
R161 INN.n15 INN.n2 11.6805
R162 INN.n19 INN.n0 10.8396
R163 INN.n19 INN.n18 9.0005
R164 INN.n8 INN.n6 7.17687
R165 INN.n18 INN.n17 7.05405
R166 INN.n17 INN.n16 4.4296
R167 INN.n9 INN.n8 4.42851
R168 INN.n4 INN.n1 0.1205
R169 INN.n5 INN.n4 0.1205
R170 INN.n6 INN.n5 0.1205
R171 INN.n14 INN.n13 0.1205
R172 INN.n13 INN.n12 0.1205
R173 INN.n12 INN.n3 0.1205
R174 INN.n7 INN.n3 0.1205
R175 INN.n18 INN.n1 0.1085
R176 INN.n14 INN.n0 0.1085
R177 INP.t7 INP.n8 127.788
R178 INP.t0 INP.n0 127.776
R179 INP.t2 INP.n15 127.668
R180 INP.n14 INP.t3 127.668
R181 INP.n8 INP.t6 127.668
R182 INP.t5 INP.n5 127.668
R183 INP.n13 INP.t4 127.668
R184 INP.t1 INP.n0 127.668
R185 INP.n9 INP.t7 113.632
R186 INP.n1 INP.t0 113.629
R187 INP.n16 INP.t2 109.174
R188 INP.t3 INP.n3 109.174
R189 INP.n10 INP.t6 109.174
R190 INP.n11 INP.t5 109.174
R191 INP.t4 INP.n12 109.174
R192 INP.n4 INP.t1 109.174
R193 INP INP.n19 29.6227
R194 INP.n17 INP.n16 18.4942
R195 INP.n3 INP.n2 18.4942
R196 INP.n11 INP.n7 18.4942
R197 INP.n12 INP.n6 18.4942
R198 INP.n16 INP.n4 11.6805
R199 INP.n16 INP.n3 11.6805
R200 INP.n11 INP.n10 11.6805
R201 INP.n12 INP.n11 11.6805
R202 INP.n12 INP.n3 11.6805
R203 INP.n19 INP.n0 10.8396
R204 INP.n19 INP.n18 9.0005
R205 INP.n9 INP.n7 7.17687
R206 INP.n18 INP.n1 7.05405
R207 INP.n4 INP.n1 4.4296
R208 INP.n10 INP.n9 4.42851
R209 INP.n8 INP.n5 0.1205
R210 INP.n13 INP.n5 0.1205
R211 INP.n14 INP.n13 0.1205
R212 INP.n15 INP.n14 0.1205
R213 INP.n7 INP.n6 0.1205
R214 INP.n6 INP.n2 0.1205
R215 INP.n17 INP.n2 0.1205
R216 INP.n15 INP.n0 0.1085
R217 INP.n18 INP.n17 0.1085
R218 OUTN.n5 OUTN.n2 10.957
R219 OUTN.n5 OUTN.n4 10.5657
R220 OUTN OUTN.n5 8.59007
R221 OUTN.n1 OUTN.t3 5.7796
R222 OUTN.n4 OUTN.t4 5.71396
R223 OUTN.n2 OUTN.t0 5.68486
R224 OUTN.n1 OUTN.n0 5.38537
R225 OUTN.n4 OUTN.n3 5.34435
R226 OUTN.n3 OUTN.t2 0.228
R227 OUTN.n3 OUTN.t1 0.228
R228 OUTN.n0 OUTN.t6 0.20525
R229 OUTN.n0 OUTN.t5 0.20525
R230 OUTN.n2 OUTN.n1 0.0952368
R231 OUTP.n5 OUTP.n1 11.0353
R232 OUTP.n5 OUTP.n4 10.4875
R233 OUTP OUTP.n5 8.47267
R234 OUTP.n3 OUTP.t2 5.7796
R235 OUTP.n1 OUTP.t0 5.71396
R236 OUTP.n4 OUTP.t6 5.68486
R237 OUTP.n3 OUTP.n2 5.38537
R238 OUTP.n1 OUTP.n0 5.34435
R239 OUTP.n0 OUTP.t4 0.228
R240 OUTP.n0 OUTP.t1 0.228
R241 OUTP.n2 OUTP.t5 0.20525
R242 OUTP.n2 OUTP.t3 0.20525
R243 OUTP.n4 OUTP.n3 0.0952368
R244 SENSE_CLK.n58 SENSE_CLK.t0 139.702
R245 SENSE_CLK.n60 SENSE_CLK.t2 135.246
R246 SENSE_CLK.n61 SENSE_CLK.t3 135.246
R247 SENSE_CLK.n62 SENSE_CLK.t4 135.246
R248 SENSE_CLK.n57 SENSE_CLK.t1 135.246
R249 SENSE_CLK.t14 SENSE_CLK.n8 127.788
R250 SENSE_CLK.t26 SENSE_CLK.n45 127.788
R251 SENSE_CLK.t31 SENSE_CLK.n87 127.788
R252 SENSE_CLK.t19 SENSE_CLK.n35 127.776
R253 SENSE_CLK.t5 SENSE_CLK.n0 127.668
R254 SENSE_CLK.t6 SENSE_CLK.n23 127.668
R255 SENSE_CLK.n22 SENSE_CLK.t7 127.668
R256 SENSE_CLK.n21 SENSE_CLK.t8 127.668
R257 SENSE_CLK.t9 SENSE_CLK.n3 127.668
R258 SENSE_CLK.t10 SENSE_CLK.n15 127.668
R259 SENSE_CLK.n14 SENSE_CLK.t11 127.668
R260 SENSE_CLK.n13 SENSE_CLK.t12 127.668
R261 SENSE_CLK.t13 SENSE_CLK.n8 127.668
R262 SENSE_CLK.n45 SENSE_CLK.t25 127.668
R263 SENSE_CLK.n44 SENSE_CLK.t24 127.668
R264 SENSE_CLK.n43 SENSE_CLK.t23 127.668
R265 SENSE_CLK.n42 SENSE_CLK.t22 127.668
R266 SENSE_CLK.n41 SENSE_CLK.t21 127.668
R267 SENSE_CLK.t20 SENSE_CLK.n35 127.668
R268 SENSE_CLK.t40 SENSE_CLK.n72 127.668
R269 SENSE_CLK.n87 SENSE_CLK.t32 127.668
R270 SENSE_CLK.n86 SENSE_CLK.t33 127.668
R271 SENSE_CLK.n85 SENSE_CLK.t34 127.668
R272 SENSE_CLK.n84 SENSE_CLK.t35 127.668
R273 SENSE_CLK.n83 SENSE_CLK.t36 127.668
R274 SENSE_CLK.n82 SENSE_CLK.t37 127.668
R275 SENSE_CLK.n81 SENSE_CLK.t38 127.668
R276 SENSE_CLK.n80 SENSE_CLK.t39 127.668
R277 SENSE_CLK.n29 SENSE_CLK.t18 113.632
R278 SENSE_CLK.n10 SENSE_CLK.t14 113.632
R279 SENSE_CLK.n66 SENSE_CLK.t30 113.632
R280 SENSE_CLK.n46 SENSE_CLK.t26 113.632
R281 SENSE_CLK.n88 SENSE_CLK.t31 113.632
R282 SENSE_CLK.n36 SENSE_CLK.t19 113.629
R283 SENSE_CLK.n30 SENSE_CLK.t17 109.174
R284 SENSE_CLK.n31 SENSE_CLK.t16 109.174
R285 SENSE_CLK.n28 SENSE_CLK.t15 109.174
R286 SENSE_CLK.n25 SENSE_CLK.t5 109.174
R287 SENSE_CLK.n24 SENSE_CLK.t6 109.174
R288 SENSE_CLK.t7 SENSE_CLK.n2 109.174
R289 SENSE_CLK.t8 SENSE_CLK.n20 109.174
R290 SENSE_CLK.n4 SENSE_CLK.t9 109.174
R291 SENSE_CLK.n16 SENSE_CLK.t10 109.174
R292 SENSE_CLK.t11 SENSE_CLK.n7 109.174
R293 SENSE_CLK.t12 SENSE_CLK.n12 109.174
R294 SENSE_CLK.n9 SENSE_CLK.t13 109.174
R295 SENSE_CLK.n67 SENSE_CLK.t29 109.174
R296 SENSE_CLK.n68 SENSE_CLK.t28 109.174
R297 SENSE_CLK.n65 SENSE_CLK.t27 109.174
R298 SENSE_CLK.t25 SENSE_CLK.n40 109.174
R299 SENSE_CLK.n48 SENSE_CLK.t24 109.174
R300 SENSE_CLK.n49 SENSE_CLK.t23 109.174
R301 SENSE_CLK.n50 SENSE_CLK.t22 109.174
R302 SENSE_CLK.n51 SENSE_CLK.t21 109.174
R303 SENSE_CLK.n38 SENSE_CLK.t20 109.174
R304 SENSE_CLK.n97 SENSE_CLK.t40 109.174
R305 SENSE_CLK.n89 SENSE_CLK.t32 109.174
R306 SENSE_CLK.n90 SENSE_CLK.t33 109.174
R307 SENSE_CLK.n91 SENSE_CLK.t34 109.174
R308 SENSE_CLK.n92 SENSE_CLK.t35 109.174
R309 SENSE_CLK.n93 SENSE_CLK.t36 109.174
R310 SENSE_CLK.n94 SENSE_CLK.t37 109.174
R311 SENSE_CLK.n95 SENSE_CLK.t38 109.174
R312 SENSE_CLK.n96 SENSE_CLK.t39 109.174
R313 SENSE_CLK.n34 SENSE_CLK.n33 24.5548
R314 SENSE_CLK.n71 SENSE_CLK.n70 24.5548
R315 SENSE_CLK.n34 SENSE_CLK.n27 20.0548
R316 SENSE_CLK.n63 SENSE_CLK.n62 18.5723
R317 SENSE_CLK.n33 SENSE_CLK.n28 18.5179
R318 SENSE_CLK.n70 SENSE_CLK.n65 18.5179
R319 SENSE_CLK.n32 SENSE_CLK.n31 18.4942
R320 SENSE_CLK.n60 SENSE_CLK.n59 18.4942
R321 SENSE_CLK.n61 SENSE_CLK.n56 18.4942
R322 SENSE_CLK.n26 SENSE_CLK.n25 18.4942
R323 SENSE_CLK.n24 SENSE_CLK.n1 18.4942
R324 SENSE_CLK.n5 SENSE_CLK.n2 18.4942
R325 SENSE_CLK.n20 SENSE_CLK.n19 18.4942
R326 SENSE_CLK.n18 SENSE_CLK.n4 18.4942
R327 SENSE_CLK.n17 SENSE_CLK.n16 18.4942
R328 SENSE_CLK.n7 SENSE_CLK.n6 18.4942
R329 SENSE_CLK.n12 SENSE_CLK.n11 18.4942
R330 SENSE_CLK.n69 SENSE_CLK.n68 18.4942
R331 SENSE_CLK.n48 SENSE_CLK.n47 18.4942
R332 SENSE_CLK.n49 SENSE_CLK.n39 18.4942
R333 SENSE_CLK.n50 SENSE_CLK.n37 18.4942
R334 SENSE_CLK.n52 SENSE_CLK.n51 18.4942
R335 SENSE_CLK.n98 SENSE_CLK.n97 18.4942
R336 SENSE_CLK.n90 SENSE_CLK.n79 18.4942
R337 SENSE_CLK.n91 SENSE_CLK.n78 18.4942
R338 SENSE_CLK.n92 SENSE_CLK.n77 18.4942
R339 SENSE_CLK.n93 SENSE_CLK.n76 18.4942
R340 SENSE_CLK.n94 SENSE_CLK.n75 18.4942
R341 SENSE_CLK.n95 SENSE_CLK.n74 18.4942
R342 SENSE_CLK.n96 SENSE_CLK.n73 18.4942
R343 SENSE_CLK.n55 SENSE_CLK.n54 15.5548
R344 SENSE_CLK.n100 SENSE_CLK.n99 15.5548
R345 SENSE_CLK.n64 SENSE_CLK.n63 14.5766
R346 SENSE_CLK SENSE_CLK.n100 13.9118
R347 SENSE_CLK.n31 SENSE_CLK.n30 11.6805
R348 SENSE_CLK.n31 SENSE_CLK.n28 11.6805
R349 SENSE_CLK.n60 SENSE_CLK.n57 11.6805
R350 SENSE_CLK.n61 SENSE_CLK.n60 11.6805
R351 SENSE_CLK.n62 SENSE_CLK.n61 11.6805
R352 SENSE_CLK.n25 SENSE_CLK.n24 11.6805
R353 SENSE_CLK.n24 SENSE_CLK.n2 11.6805
R354 SENSE_CLK.n20 SENSE_CLK.n2 11.6805
R355 SENSE_CLK.n20 SENSE_CLK.n4 11.6805
R356 SENSE_CLK.n16 SENSE_CLK.n4 11.6805
R357 SENSE_CLK.n16 SENSE_CLK.n7 11.6805
R358 SENSE_CLK.n12 SENSE_CLK.n7 11.6805
R359 SENSE_CLK.n12 SENSE_CLK.n9 11.6805
R360 SENSE_CLK.n68 SENSE_CLK.n67 11.6805
R361 SENSE_CLK.n68 SENSE_CLK.n65 11.6805
R362 SENSE_CLK.n49 SENSE_CLK.n48 11.6805
R363 SENSE_CLK.n48 SENSE_CLK.n40 11.6805
R364 SENSE_CLK.n50 SENSE_CLK.n49 11.6805
R365 SENSE_CLK.n51 SENSE_CLK.n50 11.6805
R366 SENSE_CLK.n51 SENSE_CLK.n38 11.6805
R367 SENSE_CLK.n90 SENSE_CLK.n89 11.6805
R368 SENSE_CLK.n91 SENSE_CLK.n90 11.6805
R369 SENSE_CLK.n92 SENSE_CLK.n91 11.6805
R370 SENSE_CLK.n93 SENSE_CLK.n92 11.6805
R371 SENSE_CLK.n94 SENSE_CLK.n93 11.6805
R372 SENSE_CLK.n95 SENSE_CLK.n94 11.6805
R373 SENSE_CLK.n96 SENSE_CLK.n95 11.6805
R374 SENSE_CLK.n97 SENSE_CLK.n96 11.6805
R375 SENSE_CLK.n27 SENSE_CLK.n0 11.1876
R376 SENSE_CLK.n99 SENSE_CLK.n72 11.0376
R377 SENSE_CLK.n54 SENSE_CLK.n35 10.8396
R378 SENSE_CLK.n27 SENSE_CLK.n26 9.3485
R379 SENSE_CLK.n99 SENSE_CLK.n98 9.1985
R380 SENSE_CLK.n54 SENSE_CLK.n53 9.0005
R381 SENSE_CLK.n32 SENSE_CLK.n29 7.17687
R382 SENSE_CLK.n59 SENSE_CLK.n58 7.17687
R383 SENSE_CLK.n11 SENSE_CLK.n10 7.17687
R384 SENSE_CLK.n69 SENSE_CLK.n66 7.17687
R385 SENSE_CLK.n47 SENSE_CLK.n46 7.17687
R386 SENSE_CLK.n88 SENSE_CLK.n79 7.17687
R387 SENSE_CLK.n53 SENSE_CLK.n36 7.05405
R388 SENSE_CLK.n100 SENSE_CLK.n71 4.69615
R389 SENSE_CLK.n38 SENSE_CLK.n36 4.4296
R390 SENSE_CLK.n30 SENSE_CLK.n29 4.42851
R391 SENSE_CLK.n58 SENSE_CLK.n57 4.42851
R392 SENSE_CLK.n10 SENSE_CLK.n9 4.42851
R393 SENSE_CLK.n67 SENSE_CLK.n66 4.42851
R394 SENSE_CLK.n46 SENSE_CLK.n40 4.42851
R395 SENSE_CLK.n89 SENSE_CLK.n88 4.42851
R396 SENSE_CLK.n55 SENSE_CLK.n34 3.32659
R397 SENSE_CLK.n71 SENSE_CLK.n64 2.73963
R398 SENSE_CLK.n64 SENSE_CLK.n55 0.978761
R399 SENSE_CLK.n11 SENSE_CLK.n6 0.1205
R400 SENSE_CLK.n17 SENSE_CLK.n6 0.1205
R401 SENSE_CLK.n18 SENSE_CLK.n17 0.1205
R402 SENSE_CLK.n19 SENSE_CLK.n18 0.1205
R403 SENSE_CLK.n19 SENSE_CLK.n5 0.1205
R404 SENSE_CLK.n5 SENSE_CLK.n1 0.1205
R405 SENSE_CLK.n26 SENSE_CLK.n1 0.1205
R406 SENSE_CLK.n13 SENSE_CLK.n8 0.1205
R407 SENSE_CLK.n14 SENSE_CLK.n13 0.1205
R408 SENSE_CLK.n15 SENSE_CLK.n14 0.1205
R409 SENSE_CLK.n15 SENSE_CLK.n3 0.1205
R410 SENSE_CLK.n21 SENSE_CLK.n3 0.1205
R411 SENSE_CLK.n22 SENSE_CLK.n21 0.1205
R412 SENSE_CLK.n23 SENSE_CLK.n22 0.1205
R413 SENSE_CLK.n23 SENSE_CLK.n0 0.1205
R414 SENSE_CLK.n45 SENSE_CLK.n44 0.1205
R415 SENSE_CLK.n44 SENSE_CLK.n43 0.1205
R416 SENSE_CLK.n43 SENSE_CLK.n42 0.1205
R417 SENSE_CLK.n42 SENSE_CLK.n41 0.1205
R418 SENSE_CLK.n47 SENSE_CLK.n39 0.1205
R419 SENSE_CLK.n39 SENSE_CLK.n37 0.1205
R420 SENSE_CLK.n52 SENSE_CLK.n37 0.1205
R421 SENSE_CLK.n98 SENSE_CLK.n73 0.1205
R422 SENSE_CLK.n74 SENSE_CLK.n73 0.1205
R423 SENSE_CLK.n75 SENSE_CLK.n74 0.1205
R424 SENSE_CLK.n76 SENSE_CLK.n75 0.1205
R425 SENSE_CLK.n77 SENSE_CLK.n76 0.1205
R426 SENSE_CLK.n78 SENSE_CLK.n77 0.1205
R427 SENSE_CLK.n79 SENSE_CLK.n78 0.1205
R428 SENSE_CLK.n80 SENSE_CLK.n72 0.1205
R429 SENSE_CLK.n81 SENSE_CLK.n80 0.1205
R430 SENSE_CLK.n82 SENSE_CLK.n81 0.1205
R431 SENSE_CLK.n83 SENSE_CLK.n82 0.1205
R432 SENSE_CLK.n84 SENSE_CLK.n83 0.1205
R433 SENSE_CLK.n85 SENSE_CLK.n84 0.1205
R434 SENSE_CLK.n86 SENSE_CLK.n85 0.1205
R435 SENSE_CLK.n87 SENSE_CLK.n86 0.1205
R436 SENSE_CLK.n59 SENSE_CLK.n56 0.114816
R437 SENSE_CLK.n41 SENSE_CLK.n35 0.1085
R438 SENSE_CLK.n53 SENSE_CLK.n52 0.1085
R439 SENSE_CLK.n33 SENSE_CLK.n32 0.0785
R440 SENSE_CLK.n70 SENSE_CLK.n69 0.0785
R441 SENSE_CLK.n63 SENSE_CLK.n56 0.0241842
R442 VDD.n81 VDD.n80 166.667
R443 VDD.n72 VDD.n71 166.667
R444 VDD.n39 VDD.n22 166.667
R445 VDD.n31 VDD.n30 166.667
R446 VDD.n71 VDD.t102 120.001
R447 VDD.t100 VDD.n22 120.001
R448 VDD.n56 VDD.t74 113.334
R449 VDD.t106 VDD.t44 113.334
R450 VDD.t51 VDD.t128 113.334
R451 VDD.t124 VDD.n45 113.334
R452 VDD.n83 VDD.n82 106.3
R453 VDD.n29 VDD.n28 106.3
R454 VDD.n72 VDD.t114 80.0005
R455 VDD.n57 VDD.t42 80.0005
R456 VDD.t52 VDD.n44 80.0005
R457 VDD.t130 VDD.n39 80.0005
R458 VDD.n83 VDD.n4 70.0005
R459 VDD.n79 VDD.n4 70.0005
R460 VDD.n79 VDD.n5 70.0005
R461 VDD.n73 VDD.n5 70.0005
R462 VDD.n73 VDD.n9 70.0005
R463 VDD.n65 VDD.n9 70.0005
R464 VDD.n65 VDD.n11 70.0005
R465 VDD.n59 VDD.n11 70.0005
R466 VDD.n59 VDD.n15 70.0005
R467 VDD.n53 VDD.n15 70.0005
R468 VDD.n53 VDD.n16 70.0005
R469 VDD.n47 VDD.n16 70.0005
R470 VDD.n47 VDD.n20 70.0005
R471 VDD.n38 VDD.n20 70.0005
R472 VDD.n38 VDD.n23 70.0005
R473 VDD.n32 VDD.n23 70.0005
R474 VDD.n32 VDD.n27 70.0005
R475 VDD.n28 VDD.n27 70.0005
R476 VDD.n82 VDD.n81 66.6672
R477 VDD.n30 VDD.n29 66.6672
R478 VDD.n67 VDD.t0 46.6672
R479 VDD.n40 VDD.t96 46.6672
R480 VDD.t34 VDD.n66 40.0005
R481 VDD.n46 VDD.t68 40.0005
R482 VDD.t84 VDD.n57 26.6672
R483 VDD.n44 VDD.t110 26.6672
R484 VDD.n80 VDD.t2 20.0005
R485 VDD.n31 VDD.t78 20.0005
R486 VDD.n93 VDD.n92 19.9029
R487 VDD.n134 VDD.n133 19.8556
R488 VDD.n101 VDD.n100 19.4435
R489 VDD.n165 VDD.n164 19.0889
R490 VDD.n105 VDD.n104 19.0179
R491 VDD.n98 VDD.n97 19.0179
R492 VDD.n90 VDD.n89 19.0179
R493 VDD.n161 VDD.n160 19.0179
R494 VDD.n85 VDD.n84 18.1338
R495 VDD.n3 VDD.n2 18.0005
R496 VDD.n78 VDD.n77 18.0005
R497 VDD.n76 VDD.n6 18.0005
R498 VDD.n75 VDD.n74 18.0005
R499 VDD.n8 VDD.n7 18.0005
R500 VDD.n64 VDD.n63 18.0005
R501 VDD.n62 VDD.n12 18.0005
R502 VDD.n61 VDD.n60 18.0005
R503 VDD.n14 VDD.n13 18.0005
R504 VDD.n52 VDD.n51 18.0005
R505 VDD.n50 VDD.n17 18.0005
R506 VDD.n49 VDD.n48 18.0005
R507 VDD.n19 VDD.n18 18.0005
R508 VDD.n37 VDD.n36 18.0005
R509 VDD.n35 VDD.n24 18.0005
R510 VDD.n34 VDD.n33 18.0005
R511 VDD.n29 VDD.n21 17.6387
R512 VDD.n128 VDD.n127 16.6701
R513 VDD.n139 VDD.n138 16.6701
R514 VDD.n82 VDD.n1 16.3758
R515 VDD.n71 VDD.n70 16.3758
R516 VDD.n69 VDD.n68 16.3758
R517 VDD.n57 VDD.n10 16.3758
R518 VDD.n44 VDD.n43 16.3758
R519 VDD.n42 VDD.n41 16.3758
R520 VDD.n22 VDD.n21 16.3758
R521 VDD.n123 VDD.n122 14.4407
R522 VDD.n143 VDD.n142 14.3222
R523 VDD.t118 VDD.t2 13.3338
R524 VDD.t102 VDD.t118 13.3338
R525 VDD.t126 VDD.t114 13.3338
R526 VDD.t122 VDD.t126 13.3338
R527 VDD.t0 VDD.t122 13.3338
R528 VDD.t16 VDD.t20 13.3338
R529 VDD.t18 VDD.t16 13.3338
R530 VDD.t22 VDD.t18 13.3338
R531 VDD.t24 VDD.t22 13.3338
R532 VDD.n66 VDD.t88 13.3338
R533 VDD.t72 VDD.t88 13.3338
R534 VDD.t90 VDD.t72 13.3338
R535 VDD.t74 VDD.t90 13.3338
R536 VDD.t36 VDD.n56 13.3338
R537 VDD.t38 VDD.t36 13.3338
R538 VDD.t40 VDD.t38 13.3338
R539 VDD.t42 VDD.t40 13.3338
R540 VDD.t44 VDD.t45 13.3338
R541 VDD.t45 VDD.t46 13.3338
R542 VDD.t46 VDD.t47 13.3338
R543 VDD.t48 VDD.t49 13.3338
R544 VDD.t49 VDD.t50 13.3338
R545 VDD.t50 VDD.t51 13.3338
R546 VDD.t54 VDD.t52 13.3338
R547 VDD.t56 VDD.t54 13.3338
R548 VDD.t14 VDD.t56 13.3338
R549 VDD.n45 VDD.t14 13.3338
R550 VDD.t120 VDD.t124 13.3338
R551 VDD.t4 VDD.t120 13.3338
R552 VDD.t104 VDD.t4 13.3338
R553 VDD.n46 VDD.t104 13.3338
R554 VDD.t58 VDD.t10 13.3338
R555 VDD.t10 VDD.t64 13.3338
R556 VDD.t64 VDD.t8 13.3338
R557 VDD.t8 VDD.t60 13.3338
R558 VDD.t96 VDD.t80 13.3338
R559 VDD.t80 VDD.t112 13.3338
R560 VDD.t112 VDD.t130 13.3338
R561 VDD.t94 VDD.t100 13.3338
R562 VDD.t78 VDD.t94 13.3338
R563 VDD.n34 VDD.n25 9.31191
R564 VDD.n115 VDD.n114 8.55306
R565 VDD.n153 VDD.n152 8.42404
R566 VDD.n28 VDD.n25 6.79358
R567 VDD.t20 VDD.n67 6.66717
R568 VDD.n68 VDD.t24 6.66717
R569 VDD.n68 VDD.t26 6.66717
R570 VDD.t26 VDD.t98 6.66717
R571 VDD.t98 VDD.t28 6.66717
R572 VDD.t28 VDD.t82 6.66717
R573 VDD.t82 VDD.t30 6.66717
R574 VDD.t30 VDD.t116 6.66717
R575 VDD.t116 VDD.t32 6.66717
R576 VDD.t32 VDD.t6 6.66717
R577 VDD.t6 VDD.t34 6.66717
R578 VDD.n58 VDD.t84 6.66717
R579 VDD.n58 VDD.t106 6.66717
R580 VDD.t47 VDD.n55 6.66717
R581 VDD.n55 VDD.t48 6.66717
R582 VDD.t128 VDD.n54 6.66717
R583 VDD.n54 VDD.t110 6.66717
R584 VDD.t92 VDD.t68 6.66717
R585 VDD.t12 VDD.t92 6.66717
R586 VDD.t76 VDD.t12 6.66717
R587 VDD.t70 VDD.t76 6.66717
R588 VDD.t86 VDD.t70 6.66717
R589 VDD.t66 VDD.t86 6.66717
R590 VDD.t108 VDD.t66 6.66717
R591 VDD.t62 VDD.t108 6.66717
R592 VDD.n41 VDD.t62 6.66717
R593 VDD.n41 VDD.t58 6.66717
R594 VDD.t60 VDD.n40 6.66717
R595 VDD.n84 VDD.n83 6.3005
R596 VDD.n81 VDD.n4 6.3005
R597 VDD.n4 VDD.n3 6.3005
R598 VDD.n80 VDD.n79 6.3005
R599 VDD.n79 VDD.n78 6.3005
R600 VDD.n71 VDD.n5 6.3005
R601 VDD.n6 VDD.n5 6.3005
R602 VDD.n73 VDD.n72 6.3005
R603 VDD.n74 VDD.n73 6.3005
R604 VDD.n67 VDD.n9 6.3005
R605 VDD.n9 VDD.n8 6.3005
R606 VDD.n66 VDD.n65 6.3005
R607 VDD.n65 VDD.n64 6.3005
R608 VDD.n56 VDD.n11 6.3005
R609 VDD.n12 VDD.n11 6.3005
R610 VDD.n59 VDD.n58 6.3005
R611 VDD.n60 VDD.n59 6.3005
R612 VDD.n55 VDD.n15 6.3005
R613 VDD.n15 VDD.n14 6.3005
R614 VDD.n54 VDD.n53 6.3005
R615 VDD.n53 VDD.n52 6.3005
R616 VDD.n45 VDD.n16 6.3005
R617 VDD.n17 VDD.n16 6.3005
R618 VDD.n47 VDD.n46 6.3005
R619 VDD.n48 VDD.n47 6.3005
R620 VDD.n40 VDD.n20 6.3005
R621 VDD.n20 VDD.n19 6.3005
R622 VDD.n39 VDD.n38 6.3005
R623 VDD.n38 VDD.n37 6.3005
R624 VDD.n23 VDD.n22 6.3005
R625 VDD.n24 VDD.n23 6.3005
R626 VDD.n32 VDD.n31 6.3005
R627 VDD.n33 VDD.n32 6.3005
R628 VDD.n30 VDD.n27 6.3005
R629 VDD.n27 VDD.n26 6.3005
R630 VDD.n100 VDD.t79 5.54817
R631 VDD.n164 VDD.t103 5.54817
R632 VDD.n100 VDD.n99 5.51014
R633 VDD.n104 VDD.n103 5.51014
R634 VDD.n108 VDD.n106 5.51014
R635 VDD.n122 VDD.n120 5.51014
R636 VDD.n127 VDD.n126 5.51014
R637 VDD.n138 VDD.n137 5.51014
R638 VDD.n142 VDD.n141 5.51014
R639 VDD.n146 VDD.n144 5.51014
R640 VDD.n89 VDD.n88 5.51014
R641 VDD.n160 VDD.n159 5.51014
R642 VDD.n164 VDD.n163 5.51014
R643 VDD.n97 VDD.n95 5.43909
R644 VDD.n97 VDD.n96 5.39172
R645 VDD.n104 VDD.n102 5.32067
R646 VDD.n114 VDD.n113 5.32067
R647 VDD.n112 VDD.n111 5.32067
R648 VDD.n110 VDD.n109 5.32067
R649 VDD.n108 VDD.n107 5.32067
R650 VDD.n122 VDD.n121 5.32067
R651 VDD.n127 VDD.n125 5.32067
R652 VDD.n138 VDD.n136 5.32067
R653 VDD.n142 VDD.n140 5.32067
R654 VDD.n152 VDD.n151 5.32067
R655 VDD.n150 VDD.n149 5.32067
R656 VDD.n148 VDD.n147 5.32067
R657 VDD.n146 VDD.n145 5.32067
R658 VDD.n89 VDD.n87 5.32067
R659 VDD.n160 VDD.n158 5.32067
R660 VDD.n168 VDD.n0 4.5005
R661 VDD.n167 VDD.n166 4.5005
R662 VDD.n162 VDD.n86 4.5005
R663 VDD.n157 VDD.n156 4.5005
R664 VDD.n155 VDD.n154 4.5005
R665 VDD.n135 VDD.n91 4.5005
R666 VDD.n132 VDD.n131 4.5005
R667 VDD.n130 VDD.n129 4.5005
R668 VDD.n124 VDD.n94 4.5005
R669 VDD.n119 VDD.n118 4.5005
R670 VDD.n117 VDD.n116 4.5005
R671 VDD.n170 VDD.n0 3.0937
R672 VDD.n117 VDD.n101 1.76125
R673 VDD.n105 VDD.n101 1.39974
R674 VDD.n70 VDD.n1 1.26366
R675 VDD.n70 VDD.n69 1.26366
R676 VDD.n69 VDD.n10 1.26366
R677 VDD.n43 VDD.n10 1.26366
R678 VDD.n43 VDD.n42 1.26366
R679 VDD.n42 VDD.n21 1.26366
R680 VDD.n84 VDD.n3 1.0005
R681 VDD.n78 VDD.n3 1.0005
R682 VDD.n78 VDD.n6 1.0005
R683 VDD.n74 VDD.n6 1.0005
R684 VDD.n74 VDD.n8 1.0005
R685 VDD.n64 VDD.n8 1.0005
R686 VDD.n64 VDD.n12 1.0005
R687 VDD.n60 VDD.n12 1.0005
R688 VDD.n60 VDD.n14 1.0005
R689 VDD.n52 VDD.n14 1.0005
R690 VDD.n52 VDD.n17 1.0005
R691 VDD.n48 VDD.n17 1.0005
R692 VDD.n48 VDD.n19 1.0005
R693 VDD.n37 VDD.n19 1.0005
R694 VDD.n37 VDD.n24 1.0005
R695 VDD.n33 VDD.n24 1.0005
R696 VDD.n33 VDD.n26 1.0005
R697 VDD.n166 VDD.n162 0.9005
R698 VDD.n132 VDD.n93 0.8855
R699 VDD.n129 VDD.n128 0.8105
R700 VDD.n143 VDD.n139 0.7505
R701 VDD.n165 VDD.n0 0.7355
R702 VDD.n124 VDD.n123 0.7355
R703 VDD.n162 VDD.n161 0.6605
R704 VDD.n115 VDD.n98 0.622051
R705 VDD.n135 VDD.n134 0.5855
R706 VDD.n157 VDD.n90 0.5105
R707 VDD.n26 VDD.n25 0.481712
R708 VDD.n77 VDD.n2 0.444944
R709 VDD.n77 VDD.n76 0.444944
R710 VDD.n76 VDD.n75 0.444944
R711 VDD.n75 VDD.n7 0.444944
R712 VDD.n63 VDD.n7 0.444944
R713 VDD.n63 VDD.n62 0.444944
R714 VDD.n62 VDD.n61 0.444944
R715 VDD.n61 VDD.n13 0.444944
R716 VDD.n51 VDD.n13 0.444944
R717 VDD.n51 VDD.n50 0.444944
R718 VDD.n50 VDD.n49 0.444944
R719 VDD.n49 VDD.n18 0.444944
R720 VDD.n36 VDD.n18 0.444944
R721 VDD.n36 VDD.n35 0.444944
R722 VDD.n35 VDD.n34 0.444944
R723 VDD.n168 VDD.n167 0.4005
R724 VDD.n167 VDD.n86 0.4005
R725 VDD.n156 VDD.n86 0.4005
R726 VDD.n156 VDD.n155 0.4005
R727 VDD.n155 VDD.n91 0.4005
R728 VDD.n131 VDD.n91 0.4005
R729 VDD.n131 VDD.n130 0.4005
R730 VDD.n130 VDD.n94 0.4005
R731 VDD.n118 VDD.n94 0.4005
R732 VDD.n118 VDD.n117 0.4005
R733 VDD.n169 VDD.n168 0.367167
R734 VDD.n134 VDD.n132 0.3155
R735 VDD.n85 VDD.n2 0.311611
R736 VDD.n169 VDD.n1 0.264711
R737 VDD.n154 VDD.n153 0.256124
R738 VDD.n161 VDD.n157 0.2405
R739 VDD.n99 VDD.t101 0.228
R740 VDD.n99 VDD.t95 0.228
R741 VDD.n102 VDD.t113 0.228
R742 VDD.n102 VDD.t131 0.228
R743 VDD.n103 VDD.t97 0.228
R744 VDD.n103 VDD.t81 0.228
R745 VDD.n113 VDD.t9 0.228
R746 VDD.n113 VDD.t61 0.228
R747 VDD.n111 VDD.t11 0.228
R748 VDD.n111 VDD.t65 0.228
R749 VDD.n109 VDD.t63 0.228
R750 VDD.n109 VDD.t59 0.228
R751 VDD.n107 VDD.t71 0.228
R752 VDD.n107 VDD.t67 0.228
R753 VDD.n106 VDD.t69 0.228
R754 VDD.n106 VDD.t13 0.228
R755 VDD.n95 VDD.t87 0.228
R756 VDD.n95 VDD.t109 0.228
R757 VDD.n96 VDD.t93 0.228
R758 VDD.n96 VDD.t77 0.228
R759 VDD.n121 VDD.t5 0.228
R760 VDD.n121 VDD.t105 0.228
R761 VDD.n120 VDD.t125 0.228
R762 VDD.n120 VDD.t121 0.228
R763 VDD.n125 VDD.t57 0.228
R764 VDD.n125 VDD.t15 0.228
R765 VDD.n126 VDD.t53 0.228
R766 VDD.n126 VDD.t55 0.228
R767 VDD.n92 VDD.t129 0.228
R768 VDD.n92 VDD.t111 0.228
R769 VDD.n133 VDD.t85 0.228
R770 VDD.n133 VDD.t107 0.228
R771 VDD.n136 VDD.t41 0.228
R772 VDD.n136 VDD.t43 0.228
R773 VDD.n137 VDD.t37 0.228
R774 VDD.n137 VDD.t39 0.228
R775 VDD.n140 VDD.t91 0.228
R776 VDD.n140 VDD.t75 0.228
R777 VDD.n141 VDD.t89 0.228
R778 VDD.n141 VDD.t73 0.228
R779 VDD.n151 VDD.t33 0.228
R780 VDD.n151 VDD.t35 0.228
R781 VDD.n149 VDD.t29 0.228
R782 VDD.n149 VDD.t31 0.228
R783 VDD.n147 VDD.t25 0.228
R784 VDD.n147 VDD.t27 0.228
R785 VDD.n145 VDD.t19 0.228
R786 VDD.n145 VDD.t23 0.228
R787 VDD.n144 VDD.t21 0.228
R788 VDD.n144 VDD.t17 0.228
R789 VDD.n87 VDD.t117 0.228
R790 VDD.n87 VDD.t7 0.228
R791 VDD.n88 VDD.t99 0.228
R792 VDD.n88 VDD.t83 0.228
R793 VDD.n158 VDD.t123 0.228
R794 VDD.n158 VDD.t1 0.228
R795 VDD.n159 VDD.t115 0.228
R796 VDD.n159 VDD.t127 0.228
R797 VDD.n163 VDD.t3 0.228
R798 VDD.n163 VDD.t119 0.228
R799 VDD.n110 VDD.n108 0.189974
R800 VDD.n112 VDD.n110 0.189974
R801 VDD.n114 VDD.n112 0.189974
R802 VDD.n148 VDD.n146 0.189974
R803 VDD.n150 VDD.n148 0.189974
R804 VDD.n152 VDD.n150 0.189974
R805 VDD.n166 VDD.n165 0.1655
R806 VDD.n123 VDD.n119 0.1655
R807 VDD.n116 VDD.n115 0.143825
R808 VDD.n119 VDD.n98 0.1355
R809 VDD.n153 VDD.n90 0.135448
R810 VDD.n169 VDD.n85 0.124184
R811 VDD.n139 VDD.n135 0.0905
R812 VDD.n128 VDD.n124 0.0905
R813 VDD.n154 VDD.n143 0.0605
R814 VDD.n116 VDD.n105 0.0605
R815 VDD.n129 VDD.n93 0.0155
R816 VDD VDD.n170 0.0102388
R817 VDD.n170 VDD.n169 0.0100576
R818 VSS.n126 VSS.n89 325
R819 VSS.n132 VSS.n89 325
R820 VSS.n59 VSS.n20 325
R821 VSS.n53 VSS.n20 325
R822 VSS.n81 VSS.n1 260
R823 VSS.n151 VSS.n2 260
R824 VSS.t47 VSS.n133 234
R825 VSS.n21 VSS.t78 234
R826 VSS.n133 VSS.t69 221
R827 VSS.t4 VSS.n21 221
R828 VSS.n85 VSS.t44 182
R829 VSS.t30 VSS.t74 169
R830 VSS.n9 VSS.t50 169
R831 VSS.t28 VSS.t104 169
R832 VSS.n126 VSS.n125 149.5
R833 VSS.n53 VSS.n25 149.5
R834 VSS.n140 VSS.t37 117.001
R835 VSS.n47 VSS.n46 87.5005
R836 VSS.n44 VSS.n28 87.5005
R837 VSS.n40 VSS.n28 87.5005
R838 VSS.n38 VSS.n37 87.5005
R839 VSS.n34 VSS.n33 87.5005
R840 VSS.n104 VSS.n93 87.5005
R841 VSS.n104 VSS.n88 87.5005
R842 VSS.n88 VSS.n87 87.5005
R843 VSS.n87 VSS.n86 87.5005
R844 VSS.n86 VSS.n80 87.5005
R845 VSS.n141 VSS.n80 87.5005
R846 VSS.n141 VSS.n11 87.5005
R847 VSS.n145 VSS.n11 87.5005
R848 VSS.n145 VSS.n10 87.5005
R849 VSS.n10 VSS.n3 87.5005
R850 VSS.n75 VSS.n3 87.5005
R851 VSS.n75 VSS.n74 87.5005
R852 VSS.n74 VSS.n13 87.5005
R853 VSS.n65 VSS.n13 87.5005
R854 VSS.n65 VSS.n17 87.5005
R855 VSS.n60 VSS.n17 87.5005
R856 VSS.n60 VSS.n19 87.5005
R857 VSS.n52 VSS.n19 87.5005
R858 VSS.n111 VSS.n110 87.5005
R859 VSS.n115 VSS.n114 87.5005
R860 VSS.n119 VSS.n118 87.5005
R861 VSS.n123 VSS.n99 87.5005
R862 VSS.n127 VSS.n90 87.5005
R863 VSS.n131 VSS.n90 87.5005
R864 VSS.n131 VSS.n84 87.5005
R865 VSS.n135 VSS.n84 87.5005
R866 VSS.n135 VSS.n82 87.5005
R867 VSS.n139 VSS.n82 87.5005
R868 VSS.n139 VSS.n8 87.5005
R869 VSS.n146 VSS.n8 87.5005
R870 VSS.n146 VSS.n5 87.5005
R871 VSS.n150 VSS.n5 87.5005
R872 VSS.n150 VSS.n4 87.5005
R873 VSS.n72 VSS.n4 87.5005
R874 VSS.n72 VSS.n14 87.5005
R875 VSS.n68 VSS.n14 87.5005
R876 VSS.n68 VSS.n16 87.5005
R877 VSS.n58 VSS.n16 87.5005
R878 VSS.n58 VSS.n22 87.5005
R879 VSS.n54 VSS.n22 87.5005
R880 VSS.n52 VSS.n50 68.2505
R881 VSS.n107 VSS.n93 68.2505
R882 VSS.t74 VSS.n85 65.0005
R883 VSS.t104 VSS.n66 65.0005
R884 VSS.t9 VSS.t65 52.0005
R885 VSS.n127 VSS.n92 50.7505
R886 VSS.n54 VSS.n24 50.7505
R887 VSS.t58 VSS.n1 39.0005
R888 VSS.n151 VSS.t57 39.0005
R889 VSS.n152 VSS.n1 29.6637
R890 VSS.n152 VSS.n151 28.4005
R891 VSS.n98 VSS.n92 26.2505
R892 VSS.t87 VSS.n132 26.0005
R893 VSS.t85 VSS.t87 26.0005
R894 VSS.t71 VSS.t85 26.0005
R895 VSS.t69 VSS.t71 26.0005
R896 VSS.t22 VSS.t47 26.0005
R897 VSS.t20 VSS.t22 26.0005
R898 VSS.t32 VSS.t20 26.0005
R899 VSS.t18 VSS.t0 26.0005
R900 VSS.t0 VSS.t2 26.0005
R901 VSS.t2 VSS.t30 26.0005
R902 VSS.t44 VSS.t37 26.0005
R903 VSS.t68 VSS.t89 26.0005
R904 VSS.t89 VSS.t34 26.0005
R905 VSS.t34 VSS.t17 26.0005
R906 VSS.t17 VSS.t26 26.0005
R907 VSS.t26 VSS.t49 26.0005
R908 VSS.t49 VSS.t73 26.0005
R909 VSS.t73 VSS.t90 26.0005
R910 VSS.t90 VSS.t155 26.0005
R911 VSS.t155 VSS.t154 26.0005
R912 VSS.t154 VSS.t103 26.0005
R913 VSS.t103 VSS.t27 26.0005
R914 VSS.t59 VSS.t58 26.0005
R915 VSS.t59 VSS.t60 26.0005
R916 VSS.t61 VSS.t60 26.0005
R917 VSS.t62 VSS.t61 26.0005
R918 VSS.t63 VSS.t62 26.0005
R919 VSS.t64 VSS.t63 26.0005
R920 VSS.t65 VSS.t64 26.0005
R921 VSS.t11 VSS.t9 26.0005
R922 VSS.t13 VSS.t11 26.0005
R923 VSS.t15 VSS.t13 26.0005
R924 VSS.t7 VSS.t15 26.0005
R925 VSS.t50 VSS.t51 26.0005
R926 VSS.t51 VSS.t52 26.0005
R927 VSS.t52 VSS.t53 26.0005
R928 VSS.t53 VSS.t54 26.0005
R929 VSS.t54 VSS.t55 26.0005
R930 VSS.t56 VSS.t55 26.0005
R931 VSS.t57 VSS.t56 26.0005
R932 VSS.t134 VSS.t132 26.0005
R933 VSS.t138 VSS.t134 26.0005
R934 VSS.t136 VSS.t138 26.0005
R935 VSS.t76 VSS.t136 26.0005
R936 VSS.t81 VSS.t76 26.0005
R937 VSS.t142 VSS.t81 26.0005
R938 VSS.t144 VSS.t142 26.0005
R939 VSS.t118 VSS.t144 26.0005
R940 VSS.t146 VSS.t118 26.0005
R941 VSS.t148 VSS.t146 26.0005
R942 VSS.t150 VSS.t148 26.0005
R943 VSS.n66 VSS.t150 26.0005
R944 VSS.t97 VSS.t28 26.0005
R945 VSS.t95 VSS.t97 26.0005
R946 VSS.t101 VSS.t95 26.0005
R947 VSS.t99 VSS.t93 26.0005
R948 VSS.t91 VSS.t99 26.0005
R949 VSS.t78 VSS.t91 26.0005
R950 VSS.t42 VSS.t4 26.0005
R951 VSS.t40 VSS.t42 26.0005
R952 VSS.t35 VSS.t40 26.0005
R953 VSS.n59 VSS.t35 26.0005
R954 VSS.n226 VSS.t105 23.9124
R955 VSS.n197 VSS.t75 23.8177
R956 VSS.n174 VSS.n173 23.8024
R957 VSS.n183 VSS.n182 23.7551
R958 VSS.n153 VSS.n0 21.0437
R959 VSS.n140 VSS.t68 19.5005
R960 VSS.t27 VSS.n81 19.5005
R961 VSS.t24 VSS.n2 19.5005
R962 VSS.t80 VSS.t110 19.5005
R963 VSS.t152 VSS.t112 19.5005
R964 VSS.t83 VSS.t114 19.5005
R965 VSS.t6 VSS.t116 19.5005
R966 VSS.t84 VSS.t108 19.5005
R967 VSS.t46 VSS.t120 19.5005
R968 VSS.t153 VSS.t122 19.5005
R969 VSS.t39 VSS.t124 19.5005
R970 VSS.t25 VSS.t126 19.5005
R971 VSS.t67 VSS.t106 19.5005
R972 VSS.t66 VSS.t128 19.5005
R973 VSS.n187 VSS.n186 18.5679
R974 VSS.n158 VSS.n155 18.2754
R975 VSS.n196 VSS.n195 18.2754
R976 VSS.n235 VSS.n234 18.157
R977 VSS.n164 VSS.n163 18.157
R978 VSS.n193 VSS.n188 18.157
R979 VSS.n134 VSS.t32 13.0005
R980 VSS.n134 VSS.t18 13.0005
R981 VSS.n9 VSS.t7 13.0005
R982 VSS.n73 VSS.t130 13.0005
R983 VSS.n73 VSS.t132 13.0005
R984 VSS.n67 VSS.t101 13.0005
R985 VSS.n67 VSS.t93 13.0005
R986 VSS.n225 VSS.n224 11.7005
R987 VSS.n221 VSS.n208 11.7005
R988 VSS.n181 VSS.n180 11.7005
R989 VSS.t110 VSS.t24 6.5005
R990 VSS.t112 VSS.t80 6.5005
R991 VSS.t114 VSS.t152 6.5005
R992 VSS.t116 VSS.t83 6.5005
R993 VSS.t108 VSS.t6 6.5005
R994 VSS.t120 VSS.t84 6.5005
R995 VSS.t122 VSS.t46 6.5005
R996 VSS.t124 VSS.t153 6.5005
R997 VSS.t126 VSS.t39 6.5005
R998 VSS.t106 VSS.t25 6.5005
R999 VSS.t128 VSS.t67 6.5005
R1000 VSS.t130 VSS.t66 6.5005
R1001 VSS.n180 VSS.t8 5.78141
R1002 VSS.n168 VSS.n166 5.66497
R1003 VSS.n211 VSS.n209 5.66497
R1004 VSS.n179 VSS.n177 5.66497
R1005 VSS.n234 VSS.n233 5.57485
R1006 VSS.n161 VSS.n159 5.57485
R1007 VSS.n191 VSS.n189 5.57485
R1008 VSS.n186 VSS.n185 5.57485
R1009 VSS.n168 VSS.n167 5.4755
R1010 VSS.n170 VSS.n169 5.4755
R1011 VSS.n172 VSS.n171 5.4755
R1012 VSS.n223 VSS.n222 5.4755
R1013 VSS.n221 VSS.n220 5.4755
R1014 VSS.n219 VSS.n218 5.4755
R1015 VSS.n217 VSS.n216 5.4755
R1016 VSS.n215 VSS.n214 5.4755
R1017 VSS.n213 VSS.n212 5.4755
R1018 VSS.n211 VSS.n210 5.4755
R1019 VSS.n179 VSS.n178 5.4755
R1020 VSS.n234 VSS.n232 5.38537
R1021 VSS.n158 VSS.n157 5.38537
R1022 VSS.n163 VSS.n162 5.38537
R1023 VSS.n161 VSS.n160 5.38537
R1024 VSS.n195 VSS.n194 5.38537
R1025 VSS.n193 VSS.n192 5.38537
R1026 VSS.n191 VSS.n190 5.38537
R1027 VSS.n186 VSS.n184 5.38537
R1028 VSS.n53 VSS.n52 5.2005
R1029 VSS.n52 VSS.n51 5.2005
R1030 VSS.n20 VSS.n19 5.2005
R1031 VSS.n19 VSS.n18 5.2005
R1032 VSS.n60 VSS.n59 5.2005
R1033 VSS.n61 VSS.n60 5.2005
R1034 VSS.n21 VSS.n17 5.2005
R1035 VSS.n62 VSS.n17 5.2005
R1036 VSS.n67 VSS.n65 5.2005
R1037 VSS.n65 VSS.n64 5.2005
R1038 VSS.n66 VSS.n13 5.2005
R1039 VSS.n63 VSS.n13 5.2005
R1040 VSS.n74 VSS.n73 5.2005
R1041 VSS.n74 VSS.n12 5.2005
R1042 VSS.n75 VSS.n2 5.2005
R1043 VSS.n76 VSS.n75 5.2005
R1044 VSS.t56 VSS.n3 5.2005
R1045 VSS.n77 VSS.n3 5.2005
R1046 VSS.n10 VSS.n9 5.2005
R1047 VSS.n78 VSS.n10 5.2005
R1048 VSS.t59 VSS.n145 5.2005
R1049 VSS.n145 VSS.n144 5.2005
R1050 VSS.n81 VSS.n11 5.2005
R1051 VSS.n143 VSS.n11 5.2005
R1052 VSS.n141 VSS.n140 5.2005
R1053 VSS.n142 VSS.n141 5.2005
R1054 VSS.n85 VSS.n80 5.2005
R1055 VSS.n80 VSS.n79 5.2005
R1056 VSS.n134 VSS.n86 5.2005
R1057 VSS.n101 VSS.n86 5.2005
R1058 VSS.n133 VSS.n87 5.2005
R1059 VSS.n102 VSS.n87 5.2005
R1060 VSS.n132 VSS.n88 5.2005
R1061 VSS.n103 VSS.n88 5.2005
R1062 VSS.n104 VSS.n89 5.2005
R1063 VSS.n105 VSS.n104 5.2005
R1064 VSS.n126 VSS.n93 5.2005
R1065 VSS.n106 VSS.n93 5.2005
R1066 VSS.n125 VSS.n92 5.2005
R1067 VSS.n92 VSS.n91 5.2005
R1068 VSS.n100 VSS.n98 5.2005
R1069 VSS.n123 VSS.n122 5.2005
R1070 VSS.n121 VSS.n99 5.2005
R1071 VSS.n120 VSS.n119 5.2005
R1072 VSS.n118 VSS.n117 5.2005
R1073 VSS.n116 VSS.n115 5.2005
R1074 VSS.n114 VSS.n113 5.2005
R1075 VSS.n112 VSS.n111 5.2005
R1076 VSS.n110 VSS.n109 5.2005
R1077 VSS.n108 VSS.n107 5.2005
R1078 VSS.n127 VSS.n126 5.2005
R1079 VSS.n128 VSS.n127 5.2005
R1080 VSS.n90 VSS.n89 5.2005
R1081 VSS.n129 VSS.n90 5.2005
R1082 VSS.n132 VSS.n131 5.2005
R1083 VSS.n131 VSS.n130 5.2005
R1084 VSS.n133 VSS.n84 5.2005
R1085 VSS.n84 VSS.n83 5.2005
R1086 VSS.n135 VSS.n134 5.2005
R1087 VSS.n136 VSS.n135 5.2005
R1088 VSS.n85 VSS.n82 5.2005
R1089 VSS.n137 VSS.n82 5.2005
R1090 VSS.n140 VSS.n139 5.2005
R1091 VSS.n139 VSS.n138 5.2005
R1092 VSS.n81 VSS.n8 5.2005
R1093 VSS.n8 VSS.n7 5.2005
R1094 VSS.n146 VSS.t59 5.2005
R1095 VSS.n147 VSS.n146 5.2005
R1096 VSS.n9 VSS.n5 5.2005
R1097 VSS.n148 VSS.n5 5.2005
R1098 VSS.t56 VSS.n150 5.2005
R1099 VSS.n150 VSS.n149 5.2005
R1100 VSS.n4 VSS.n2 5.2005
R1101 VSS.n6 VSS.n4 5.2005
R1102 VSS.n73 VSS.n72 5.2005
R1103 VSS.n72 VSS.n71 5.2005
R1104 VSS.n66 VSS.n14 5.2005
R1105 VSS.n70 VSS.n14 5.2005
R1106 VSS.n68 VSS.n67 5.2005
R1107 VSS.n69 VSS.n68 5.2005
R1108 VSS.n21 VSS.n16 5.2005
R1109 VSS.n16 VSS.n15 5.2005
R1110 VSS.n59 VSS.n58 5.2005
R1111 VSS.n58 VSS.n57 5.2005
R1112 VSS.n22 VSS.n20 5.2005
R1113 VSS.n56 VSS.n22 5.2005
R1114 VSS.n54 VSS.n53 5.2005
R1115 VSS.n55 VSS.n54 5.2005
R1116 VSS.n50 VSS.n49 5.2005
R1117 VSS.n48 VSS.n47 5.2005
R1118 VSS.n46 VSS.n27 5.2005
R1119 VSS.n44 VSS.n43 5.2005
R1120 VSS.n28 VSS.n25 5.2005
R1121 VSS.n42 VSS.n28 5.2005
R1122 VSS.n41 VSS.n40 5.2005
R1123 VSS.n38 VSS.n29 5.2005
R1124 VSS.n37 VSS.n36 5.2005
R1125 VSS.n35 VSS.n34 5.2005
R1126 VSS.n33 VSS.n31 5.2005
R1127 VSS.n24 VSS.n23 5.2005
R1128 VSS.n124 VSS.n98 4.6486
R1129 VSS.n99 VSS.n97 4.6486
R1130 VSS.n118 VSS.n96 4.6486
R1131 VSS.n114 VSS.n95 4.6486
R1132 VSS.n110 VSS.n94 4.6486
R1133 VSS.n47 VSS.n26 4.6486
R1134 VSS.n46 VSS.n45 4.6486
R1135 VSS.n40 VSS.n39 4.6486
R1136 VSS.n34 VSS.n30 4.6486
R1137 VSS.n50 VSS.n26 4.6486
R1138 VSS.n45 VSS.n44 4.6486
R1139 VSS.n39 VSS.n38 4.6486
R1140 VSS.n37 VSS.n30 4.6486
R1141 VSS.n107 VSS.n94 4.6486
R1142 VSS.n111 VSS.n95 4.6486
R1143 VSS.n115 VSS.n96 4.6486
R1144 VSS.n119 VSS.n97 4.6486
R1145 VSS.n124 VSS.n123 4.6486
R1146 VSS.n199 VSS.n198 4.5005
R1147 VSS.n201 VSS.n200 4.5005
R1148 VSS.n202 VSS.n176 4.5005
R1149 VSS.n204 VSS.n203 4.5005
R1150 VSS.n205 VSS.n175 4.5005
R1151 VSS.n207 VSS.n206 4.5005
R1152 VSS.n165 VSS.n156 4.5005
R1153 VSS.n228 VSS.n227 4.5005
R1154 VSS.n230 VSS.n229 4.5005
R1155 VSS.n231 VSS.n154 4.5005
R1156 VSS.n237 VSS.n236 4.5005
R1157 VSS.n153 VSS.n152 4.47524
R1158 VSS.n32 VSS.n24 3.72542
R1159 VSS.n33 VSS.n32 3.72542
R1160 VSS.n236 VSS.n153 2.70392
R1161 VSS.n199 VSS.n187 1.73954
R1162 VSS.n106 VSS.n105 1.1255
R1163 VSS.n105 VSS.n103 1.1255
R1164 VSS.n103 VSS.n102 1.1255
R1165 VSS.n102 VSS.n101 1.1255
R1166 VSS.n101 VSS.n79 1.1255
R1167 VSS.n142 VSS.n79 1.1255
R1168 VSS.n143 VSS.n142 1.1255
R1169 VSS.n144 VSS.n143 1.1255
R1170 VSS.n144 VSS.n78 1.1255
R1171 VSS.n78 VSS.n77 1.1255
R1172 VSS.n77 VSS.n76 1.1255
R1173 VSS.n76 VSS.n12 1.1255
R1174 VSS.n63 VSS.n12 1.1255
R1175 VSS.n64 VSS.n63 1.1255
R1176 VSS.n64 VSS.n62 1.1255
R1177 VSS.n62 VSS.n61 1.1255
R1178 VSS.n61 VSS.n18 1.1255
R1179 VSS.n51 VSS.n18 1.1255
R1180 VSS.n109 VSS.n108 1.1255
R1181 VSS.n112 VSS.n109 1.1255
R1182 VSS.n113 VSS.n112 1.1255
R1183 VSS.n116 VSS.n113 1.1255
R1184 VSS.n117 VSS.n116 1.1255
R1185 VSS.n120 VSS.n117 1.1255
R1186 VSS.n121 VSS.n120 1.1255
R1187 VSS.n122 VSS.n121 1.1255
R1188 VSS.n122 VSS.n100 1.1255
R1189 VSS.n129 VSS.n128 1.1255
R1190 VSS.n130 VSS.n129 1.1255
R1191 VSS.n130 VSS.n83 1.1255
R1192 VSS.n136 VSS.n83 1.1255
R1193 VSS.n137 VSS.n136 1.1255
R1194 VSS.n138 VSS.n137 1.1255
R1195 VSS.n138 VSS.n7 1.1255
R1196 VSS.n147 VSS.n7 1.1255
R1197 VSS.n148 VSS.n147 1.1255
R1198 VSS.n149 VSS.n148 1.1255
R1199 VSS.n149 VSS.n6 1.1255
R1200 VSS.n71 VSS.n6 1.1255
R1201 VSS.n71 VSS.n70 1.1255
R1202 VSS.n70 VSS.n69 1.1255
R1203 VSS.n69 VSS.n15 1.1255
R1204 VSS.n57 VSS.n15 1.1255
R1205 VSS.n57 VSS.n56 1.1255
R1206 VSS.n56 VSS.n55 1.1255
R1207 VSS.n49 VSS.n48 1.1255
R1208 VSS.n48 VSS.n27 1.1255
R1209 VSS.n43 VSS.n27 1.1255
R1210 VSS.n43 VSS.n42 1.1255
R1211 VSS.n42 VSS.n41 1.1255
R1212 VSS.n41 VSS.n29 1.1255
R1213 VSS.n36 VSS.n29 1.1255
R1214 VSS.n36 VSS.n35 1.1255
R1215 VSS.n35 VSS.n31 1.1255
R1216 VSS.n202 VSS.n201 0.9005
R1217 VSS.n203 VSS.n202 0.9005
R1218 VSS.n207 VSS.n175 0.9005
R1219 VSS.n231 VSS.n230 0.9005
R1220 VSS.n108 VSS.n106 0.878
R1221 VSS.n236 VSS.n235 0.8405
R1222 VSS.n208 VSS.n207 0.8105
R1223 VSS.n188 VSS.n187 0.799877
R1224 VSS.n226 VSS.n225 0.7805
R1225 VSS.n32 VSS.n25 0.73879
R1226 VSS.n181 VSS.n175 0.6905
R1227 VSS.n128 VSS.n91 0.653
R1228 VSS.n55 VSS.n23 0.653
R1229 VSS.n198 VSS.n183 0.5855
R1230 VSS.n51 VSS.n0 0.518
R1231 VSS.n227 VSS.n164 0.5105
R1232 VSS.n200 VSS.n199 0.4005
R1233 VSS.n200 VSS.n176 0.4005
R1234 VSS.n204 VSS.n176 0.4005
R1235 VSS.n205 VSS.n204 0.4005
R1236 VSS.n206 VSS.n205 0.4005
R1237 VSS.n206 VSS.n156 0.4005
R1238 VSS.n228 VSS.n156 0.4005
R1239 VSS.n229 VSS.n228 0.4005
R1240 VSS.n229 VSS.n154 0.4005
R1241 VSS.n237 VSS.n154 0.4005
R1242 VSS.n49 VSS.n0 0.3605
R1243 VSS.n100 VSS.n91 0.338
R1244 VSS.n31 VSS.n23 0.338
R1245 VSS.n197 VSS.n196 0.3305
R1246 VSS.n201 VSS.n183 0.3155
R1247 VSS.n125 VSS.n124 0.2772
R1248 VSS.n125 VSS.n97 0.2772
R1249 VSS.n125 VSS.n96 0.2772
R1250 VSS.n125 VSS.n95 0.2772
R1251 VSS.n125 VSS.n94 0.2772
R1252 VSS.n26 VSS.n25 0.2772
R1253 VSS.n45 VSS.n25 0.2772
R1254 VSS.n39 VSS.n25 0.2772
R1255 VSS.n30 VSS.n25 0.2772
R1256 VSS.n203 VSS.n181 0.2105
R1257 VSS.n232 VSS.t41 0.20525
R1258 VSS.n232 VSS.t36 0.20525
R1259 VSS.n233 VSS.t5 0.20525
R1260 VSS.n233 VSS.t43 0.20525
R1261 VSS.n157 VSS.t92 0.20525
R1262 VSS.n157 VSS.t79 0.20525
R1263 VSS.n162 VSS.t94 0.20525
R1264 VSS.n162 VSS.t100 0.20525
R1265 VSS.n160 VSS.t96 0.20525
R1266 VSS.n160 VSS.t102 0.20525
R1267 VSS.n159 VSS.t29 0.20525
R1268 VSS.n159 VSS.t98 0.20525
R1269 VSS.n173 VSS.t77 0.20525
R1270 VSS.n173 VSS.t82 0.20525
R1271 VSS.n182 VSS.t45 0.20525
R1272 VSS.n182 VSS.t38 0.20525
R1273 VSS.n194 VSS.t3 0.20525
R1274 VSS.n194 VSS.t31 0.20525
R1275 VSS.n192 VSS.t19 0.20525
R1276 VSS.n192 VSS.t1 0.20525
R1277 VSS.n190 VSS.t21 0.20525
R1278 VSS.n190 VSS.t33 0.20525
R1279 VSS.n189 VSS.t48 0.20525
R1280 VSS.n189 VSS.t23 0.20525
R1281 VSS.n184 VSS.t72 0.20525
R1282 VSS.n184 VSS.t70 0.20525
R1283 VSS.n185 VSS.t88 0.20525
R1284 VSS.n185 VSS.t86 0.20525
R1285 VSS.n196 VSS.n188 0.1955
R1286 VSS.n164 VSS.n155 0.1955
R1287 VSS.n230 VSS.n155 0.1955
R1288 VSS.n163 VSS.n161 0.189974
R1289 VSS.n163 VSS.n158 0.189974
R1290 VSS.n213 VSS.n211 0.189974
R1291 VSS.n215 VSS.n213 0.189974
R1292 VSS.n217 VSS.n215 0.189974
R1293 VSS.n219 VSS.n217 0.189974
R1294 VSS.n221 VSS.n219 0.189974
R1295 VSS.n223 VSS.n221 0.189974
R1296 VSS.n172 VSS.n170 0.189974
R1297 VSS.n170 VSS.n168 0.189974
R1298 VSS.n193 VSS.n191 0.189974
R1299 VSS.n195 VSS.n193 0.189974
R1300 VSS.n198 VSS.n197 0.1655
R1301 VSS.n166 VSS.t149 0.1643
R1302 VSS.n166 VSS.t151 0.1643
R1303 VSS.n167 VSS.t119 0.1643
R1304 VSS.n167 VSS.t147 0.1643
R1305 VSS.n169 VSS.t143 0.1643
R1306 VSS.n169 VSS.t145 0.1643
R1307 VSS.n171 VSS.t140 0.1643
R1308 VSS.n171 VSS.t141 0.1643
R1309 VSS.n222 VSS.t139 0.1643
R1310 VSS.n222 VSS.t137 0.1643
R1311 VSS.n220 VSS.t133 0.1643
R1312 VSS.n220 VSS.t135 0.1643
R1313 VSS.n218 VSS.t129 0.1643
R1314 VSS.n218 VSS.t131 0.1643
R1315 VSS.n216 VSS.t127 0.1643
R1316 VSS.n216 VSS.t107 0.1643
R1317 VSS.n214 VSS.t123 0.1643
R1318 VSS.n214 VSS.t125 0.1643
R1319 VSS.n212 VSS.t109 0.1643
R1320 VSS.n212 VSS.t121 0.1643
R1321 VSS.n210 VSS.t115 0.1643
R1322 VSS.n210 VSS.t117 0.1643
R1323 VSS.n209 VSS.t111 0.1643
R1324 VSS.n209 VSS.t113 0.1643
R1325 VSS.n178 VSS.t14 0.1643
R1326 VSS.n178 VSS.t16 0.1643
R1327 VSS.n177 VSS.t10 0.1643
R1328 VSS.n177 VSS.t12 0.1643
R1329 VSS VSS.n237 0.148833
R1330 VSS.n224 VSS.n223 0.118921
R1331 VSS.n225 VSS.n165 0.1055
R1332 VSS.n208 VSS.n174 0.0755
R1333 VSS.n224 VSS.n172 0.0715526
R1334 VSS.n235 VSS.n231 0.0605
R1335 VSS.n180 VSS.n179 0.0478684
R1336 VSS VSS.n153 0.0188333
R1337 VSS.n174 VSS.n165 0.0155
R1338 VSS.n227 VSS.n226 0.0155
R1339 NTAIL.n29 NTAIL.n22 13.0309
R1340 NTAIL.n29 NTAIL.n28 11.5048
R1341 NTAIL.n41 NTAIL.n40 11.5048
R1342 NTAIL.n34 NTAIL.n33 9.03963
R1343 NTAIL.n1 NTAIL.t44 5.82877
R1344 NTAIL.n13 NTAIL.t21 5.82877
R1345 NTAIL.n33 NTAIL.t0 5.78141
R1346 NTAIL.n32 NTAIL.n30 5.66497
R1347 NTAIL.n28 NTAIL.n23 5.57485
R1348 NTAIL.n27 NTAIL.n25 5.57485
R1349 NTAIL.n40 NTAIL.n35 5.57485
R1350 NTAIL.n39 NTAIL.n37 5.57485
R1351 NTAIL.n1 NTAIL.n0 5.4755
R1352 NTAIL.n32 NTAIL.n31 5.4755
R1353 NTAIL.n3 NTAIL.n2 5.4755
R1354 NTAIL.n5 NTAIL.n4 5.4755
R1355 NTAIL.n7 NTAIL.n6 5.4755
R1356 NTAIL.n9 NTAIL.n8 5.4755
R1357 NTAIL.n11 NTAIL.n10 5.4755
R1358 NTAIL.n21 NTAIL.n20 5.4755
R1359 NTAIL.n19 NTAIL.n18 5.4755
R1360 NTAIL.n17 NTAIL.n16 5.4755
R1361 NTAIL.n15 NTAIL.n14 5.4755
R1362 NTAIL.n13 NTAIL.n12 5.4755
R1363 NTAIL.n28 NTAIL.n24 5.38537
R1364 NTAIL.n27 NTAIL.n26 5.38537
R1365 NTAIL.n40 NTAIL.n36 5.38537
R1366 NTAIL.n39 NTAIL.n38 5.38537
R1367 NTAIL.n34 NTAIL.n29 2.27007
R1368 NTAIL.n41 NTAIL.n34 0.86137
R1369 NTAIL.n23 NTAIL.t6 0.20525
R1370 NTAIL.n23 NTAIL.t10 0.20525
R1371 NTAIL.n24 NTAIL.t7 0.20525
R1372 NTAIL.n24 NTAIL.t11 0.20525
R1373 NTAIL.n26 NTAIL.t12 0.20525
R1374 NTAIL.n26 NTAIL.t5 0.20525
R1375 NTAIL.n25 NTAIL.t8 0.20525
R1376 NTAIL.n25 NTAIL.t9 0.20525
R1377 NTAIL.n35 NTAIL.t18 0.20525
R1378 NTAIL.n35 NTAIL.t15 0.20525
R1379 NTAIL.n36 NTAIL.t16 0.20525
R1380 NTAIL.n36 NTAIL.t17 0.20525
R1381 NTAIL.n38 NTAIL.t19 0.20525
R1382 NTAIL.n38 NTAIL.t20 0.20525
R1383 NTAIL.n37 NTAIL.t13 0.20525
R1384 NTAIL.n37 NTAIL.t14 0.20525
R1385 NTAIL.n15 NTAIL.n13 0.189974
R1386 NTAIL.n17 NTAIL.n15 0.189974
R1387 NTAIL.n19 NTAIL.n17 0.189974
R1388 NTAIL.n21 NTAIL.n19 0.189974
R1389 NTAIL.n11 NTAIL.n9 0.189974
R1390 NTAIL.n9 NTAIL.n7 0.189974
R1391 NTAIL.n7 NTAIL.n5 0.189974
R1392 NTAIL.n5 NTAIL.n3 0.189974
R1393 NTAIL.n3 NTAIL.n1 0.189974
R1394 NTAIL.n28 NTAIL.n27 0.189974
R1395 NTAIL.n40 NTAIL.n39 0.189974
R1396 NTAIL.n0 NTAIL.t42 0.1643
R1397 NTAIL.n0 NTAIL.t43 0.1643
R1398 NTAIL.n30 NTAIL.t3 0.1643
R1399 NTAIL.n30 NTAIL.t4 0.1643
R1400 NTAIL.n31 NTAIL.t1 0.1643
R1401 NTAIL.n31 NTAIL.t2 0.1643
R1402 NTAIL.n2 NTAIL.t40 0.1643
R1403 NTAIL.n2 NTAIL.t41 0.1643
R1404 NTAIL.n4 NTAIL.t38 0.1643
R1405 NTAIL.n4 NTAIL.t39 0.1643
R1406 NTAIL.n6 NTAIL.t36 0.1643
R1407 NTAIL.n6 NTAIL.t37 0.1643
R1408 NTAIL.n8 NTAIL.t34 0.1643
R1409 NTAIL.n8 NTAIL.t35 0.1643
R1410 NTAIL.n10 NTAIL.t32 0.1643
R1411 NTAIL.n10 NTAIL.t33 0.1643
R1412 NTAIL.n20 NTAIL.t30 0.1643
R1413 NTAIL.n20 NTAIL.t31 0.1643
R1414 NTAIL.n18 NTAIL.t28 0.1643
R1415 NTAIL.n18 NTAIL.t29 0.1643
R1416 NTAIL.n16 NTAIL.t26 0.1643
R1417 NTAIL.n16 NTAIL.t27 0.1643
R1418 NTAIL.n14 NTAIL.t24 0.1643
R1419 NTAIL.n14 NTAIL.t25 0.1643
R1420 NTAIL.n12 NTAIL.t22 0.1643
R1421 NTAIL.n12 NTAIL.t23 0.1643
R1422 NTAIL.n22 NTAIL.n21 0.0952368
R1423 NTAIL.n22 NTAIL.n11 0.0952368
R1424 NTAIL.n33 NTAIL.n32 0.0478684
R1425 NTAIL NTAIL.n41 0.0396304
R1426 DN.t13 DN.n10 127.788
R1427 DN.t6 DN.n0 127.776
R1428 DN.n10 DN.t12 127.668
R1429 DN.n9 DN.t11 127.668
R1430 DN.n8 DN.t10 127.668
R1431 DN.n7 DN.t9 127.668
R1432 DN.n6 DN.t8 127.668
R1433 DN.t7 DN.n0 127.668
R1434 DN.n11 DN.t13 113.632
R1435 DN.n1 DN.t6 113.629
R1436 DN.t12 DN.n5 109.174
R1437 DN.n13 DN.t11 109.174
R1438 DN.n14 DN.t10 109.174
R1439 DN.n15 DN.t9 109.174
R1440 DN.n16 DN.t8 109.174
R1441 DN.n3 DN.t7 109.174
R1442 DN.n13 DN.n12 18.4942
R1443 DN.n14 DN.n4 18.4942
R1444 DN.n15 DN.n2 18.4942
R1445 DN.n17 DN.n16 18.4942
R1446 DN.n23 DN.n22 14.1606
R1447 DN.n14 DN.n13 11.6805
R1448 DN.n13 DN.n5 11.6805
R1449 DN.n15 DN.n14 11.6805
R1450 DN.n16 DN.n15 11.6805
R1451 DN.n16 DN.n3 11.6805
R1452 DN.n19 DN.n0 10.8201
R1453 DN.n25 DN.n24 10.5266
R1454 DN.n19 DN.n18 9.02007
R1455 DN.n23 DN.n19 7.2005
R1456 DN.n12 DN.n11 7.17687
R1457 DN.n18 DN.n1 7.05405
R1458 DN.n24 DN.t5 5.7796
R1459 DN.n21 DN.t2 5.73764
R1460 DN.n24 DN.t4 5.59012
R1461 DN.n22 DN.t3 5.54817
R1462 DN.n21 DN.n20 5.32067
R1463 DN.n3 DN.n1 4.4296
R1464 DN.n11 DN.n5 4.42851
R1465 DN.n25 DN.n23 0.978761
R1466 DN.n20 DN.t0 0.228
R1467 DN.n20 DN.t1 0.228
R1468 DN.n22 DN.n21 0.189974
R1469 DN.n10 DN.n9 0.1205
R1470 DN.n9 DN.n8 0.1205
R1471 DN.n8 DN.n7 0.1205
R1472 DN.n7 DN.n6 0.1205
R1473 DN.n12 DN.n4 0.1205
R1474 DN.n4 DN.n2 0.1205
R1475 DN.n17 DN.n2 0.1205
R1476 DN.n6 DN.n0 0.1085
R1477 DN.n18 DN.n17 0.1085
R1478 DN DN.n25 0.0396304
R1479 DP.t13 DP.n15 127.788
R1480 DP.t6 DP.n5 127.776
R1481 DP.n15 DP.t12 127.668
R1482 DP.n14 DP.t11 127.668
R1483 DP.n13 DP.t10 127.668
R1484 DP.n12 DP.t9 127.668
R1485 DP.n11 DP.t8 127.668
R1486 DP.t7 DP.n5 127.668
R1487 DP.n16 DP.t13 113.632
R1488 DP.n6 DP.t6 113.629
R1489 DP.t12 DP.n10 109.174
R1490 DP.n18 DP.t11 109.174
R1491 DP.n19 DP.t10 109.174
R1492 DP.n20 DP.t9 109.174
R1493 DP.n21 DP.t8 109.174
R1494 DP.n8 DP.t7 109.174
R1495 DP.n18 DP.n17 18.4942
R1496 DP.n19 DP.n9 18.4942
R1497 DP.n20 DP.n7 18.4942
R1498 DP.n22 DP.n21 18.4942
R1499 DP.n4 DP.n3 14.5055
R1500 DP.n4 DP.n0 11.7788
R1501 DP.n19 DP.n18 11.6805
R1502 DP.n18 DP.n10 11.6805
R1503 DP.n20 DP.n19 11.6805
R1504 DP.n21 DP.n20 11.6805
R1505 DP.n21 DP.n8 11.6805
R1506 DP.n24 DP.n5 10.8396
R1507 DP.n24 DP.n23 9.0005
R1508 DP.n17 DP.n16 7.17687
R1509 DP.n23 DP.n6 7.05405
R1510 DP.n2 DP.t0 5.73764
R1511 DP.n0 DP.t4 5.70855
R1512 DP.n0 DP.t3 5.66118
R1513 DP.n3 DP.t2 5.54817
R1514 DP.n2 DP.n1 5.32067
R1515 DP.n25 DP.n24 4.75485
R1516 DP.n8 DP.n6 4.4296
R1517 DP.n16 DP.n10 4.42851
R1518 DP.n25 DP.n4 1.8005
R1519 DP.n1 DP.t1 0.228
R1520 DP.n1 DP.t5 0.228
R1521 DP.n3 DP.n2 0.189974
R1522 DP.n15 DP.n14 0.1205
R1523 DP.n14 DP.n13 0.1205
R1524 DP.n13 DP.n12 0.1205
R1525 DP.n12 DP.n11 0.1205
R1526 DP.n17 DP.n9 0.1205
R1527 DP.n9 DP.n7 0.1205
R1528 DP.n22 DP.n7 0.1205
R1529 DP.n11 DP.n5 0.1085
R1530 DP.n23 DP.n22 0.1085
R1531 DP DP.n25 0.0396304
R1532 NIN.n13 NIN.n12 19.957
R1533 NIN.n13 NIN.n9 12.3657
R1534 NIN.n21 NIN.n20 11.9353
R1535 NIN.n15 NIN.t16 5.7796
R1536 NIN.n19 NIN.t9 5.7796
R1537 NIN.n11 NIN.t4 5.73764
R1538 NIN.n12 NIN.t1 5.6429
R1539 NIN.n2 NIN.n0 5.57485
R1540 NIN.n6 NIN.n4 5.57485
R1541 NIN.n2 NIN.n1 5.38537
R1542 NIN.n9 NIN.n3 5.38537
R1543 NIN.n8 NIN.n7 5.38537
R1544 NIN.n6 NIN.n5 5.38537
R1545 NIN.n15 NIN.n14 5.38537
R1546 NIN.n17 NIN.n16 5.38537
R1547 NIN.n19 NIN.n18 5.38537
R1548 NIN.n11 NIN.n10 5.32067
R1549 NIN.n21 NIN.n13 1.95702
R1550 NIN.n10 NIN.t2 0.228
R1551 NIN.n10 NIN.t3 0.228
R1552 NIN.n0 NIN.t18 0.20525
R1553 NIN.n0 NIN.t17 0.20525
R1554 NIN.n1 NIN.t7 0.20525
R1555 NIN.n1 NIN.t6 0.20525
R1556 NIN.n3 NIN.t8 0.20525
R1557 NIN.n3 NIN.t23 0.20525
R1558 NIN.n7 NIN.t0 0.20525
R1559 NIN.n7 NIN.t21 0.20525
R1560 NIN.n5 NIN.t22 0.20525
R1561 NIN.n5 NIN.t20 0.20525
R1562 NIN.n4 NIN.t5 0.20525
R1563 NIN.n4 NIN.t19 0.20525
R1564 NIN.n14 NIN.t14 0.20525
R1565 NIN.n14 NIN.t15 0.20525
R1566 NIN.n16 NIN.t12 0.20525
R1567 NIN.n16 NIN.t13 0.20525
R1568 NIN.n18 NIN.t10 0.20525
R1569 NIN.n18 NIN.t11 0.20525
R1570 NIN.n17 NIN.n15 0.189974
R1571 NIN.n8 NIN.n6 0.189974
R1572 NIN.n9 NIN.n8 0.189974
R1573 NIN.n9 NIN.n2 0.189974
R1574 NIN.n20 NIN.n19 0.0952368
R1575 NIN.n20 NIN.n17 0.0952368
R1576 NIN.n12 NIN.n11 0.0952368
R1577 NIN NIN.n21 0.0396304
R1578 NIP.n10 NIP.n9 20.2309
R1579 NIP.n10 NIP.n6 14.1657
R1580 NIP.n21 NIP.n20 10.957
R1581 NIP.n1 NIP.t16 5.7796
R1582 NIP.n5 NIP.t9 5.7796
R1583 NIP.n8 NIP.t3 5.73764
R1584 NIP.n9 NIP.t0 5.6429
R1585 NIP.n13 NIP.n11 5.57485
R1586 NIP.n17 NIP.n15 5.57485
R1587 NIP.n13 NIP.n12 5.38537
R1588 NIP.n20 NIP.n14 5.38537
R1589 NIP.n19 NIP.n18 5.38537
R1590 NIP.n17 NIP.n16 5.38537
R1591 NIP.n1 NIP.n0 5.38537
R1592 NIP.n3 NIP.n2 5.38537
R1593 NIP.n5 NIP.n4 5.38537
R1594 NIP.n8 NIP.n7 5.32067
R1595 NIP.n21 NIP.n10 1.05702
R1596 NIP.n7 NIP.t1 0.228
R1597 NIP.n7 NIP.t2 0.228
R1598 NIP.n11 NIP.t21 0.20525
R1599 NIP.n11 NIP.t6 0.20525
R1600 NIP.n12 NIP.t23 0.20525
R1601 NIP.n12 NIP.t22 0.20525
R1602 NIP.n14 NIP.t18 0.20525
R1603 NIP.n14 NIP.t20 0.20525
R1604 NIP.n18 NIP.t5 0.20525
R1605 NIP.n18 NIP.t8 0.20525
R1606 NIP.n16 NIP.t7 0.20525
R1607 NIP.n16 NIP.t4 0.20525
R1608 NIP.n15 NIP.t17 0.20525
R1609 NIP.n15 NIP.t19 0.20525
R1610 NIP.n0 NIP.t14 0.20525
R1611 NIP.n0 NIP.t15 0.20525
R1612 NIP.n2 NIP.t12 0.20525
R1613 NIP.n2 NIP.t13 0.20525
R1614 NIP.n4 NIP.t10 0.20525
R1615 NIP.n4 NIP.t11 0.20525
R1616 NIP.n3 NIP.n1 0.189974
R1617 NIP.n19 NIP.n17 0.189974
R1618 NIP.n20 NIP.n19 0.189974
R1619 NIP.n20 NIP.n13 0.189974
R1620 NIP.n6 NIP.n5 0.0952368
R1621 NIP.n6 NIP.n3 0.0952368
R1622 NIP.n9 NIP.n8 0.0952368
R1623 NIP NIP.n21 0.0396304
R1624 HB.n28 HB.t21 142.571
R1625 HB.n5 HB.t17 113.632
R1626 HB.n0 HB.t24 113.632
R1627 HB.n30 HB.t25 113.632
R1628 HB.n7 HB.t19 109.174
R1629 HB.n8 HB.t20 109.174
R1630 HB.n6 HB.t18 109.174
R1631 HB.n1 HB.t23 109.174
R1632 HB.n2 HB.t22 109.174
R1633 HB.n33 HB.t28 109.174
R1634 HB.n32 HB.t27 109.174
R1635 HB.n31 HB.t26 109.174
R1636 HB.n9 HB.n8 18.5179
R1637 HB.n7 HB.n4 18.4942
R1638 HB.n3 HB.n2 18.4942
R1639 HB.n34 HB.n33 18.4942
R1640 HB.n32 HB.n29 18.4942
R1641 HB.n27 HB.n26 17.4527
R1642 HB.n10 HB.n3 16.4663
R1643 HB.n35 HB.n34 15.8194
R1644 HB.n23 HB.t7 15.1863
R1645 HB.n10 HB.n9 14.6157
R1646 HB.n28 HB.n27 13.344
R1647 HB.n22 HB.n21 12.757
R1648 HB.n7 HB.n6 11.6805
R1649 HB.n8 HB.n7 11.6805
R1650 HB.n2 HB.n1 11.6805
R1651 HB.n33 HB.n32 11.6805
R1652 HB.n32 HB.n31 11.6805
R1653 HB.n18 HB.n17 9.43093
R1654 HB.n5 HB.n4 7.17687
R1655 HB.n3 HB.n0 7.17687
R1656 HB.n30 HB.n29 7.17687
R1657 HB.n12 HB.t15 5.7796
R1658 HB.n16 HB.t8 5.7796
R1659 HB.n20 HB.t16 5.73764
R1660 HB.n25 HB.t6 5.73764
R1661 HB.n26 HB.t3 5.71396
R1662 HB.n21 HB.t2 5.6429
R1663 HB.n12 HB.n11 5.38537
R1664 HB.n14 HB.n13 5.38537
R1665 HB.n16 HB.n15 5.38537
R1666 HB.n20 HB.n19 5.32067
R1667 HB.n25 HB.n24 5.32067
R1668 HB.n6 HB.n5 4.42851
R1669 HB.n1 HB.n0 4.42851
R1670 HB.n31 HB.n30 4.42851
R1671 HB.n18 HB.n10 3.48311
R1672 HB.n27 HB.n23 2.34833
R1673 HB.n35 HB.n28 1.17441
R1674 HB.n22 HB.n18 1.17441
R1675 HB.n23 HB.n22 0.587457
R1676 HB.n19 HB.t1 0.228
R1677 HB.n19 HB.t4 0.228
R1678 HB.n24 HB.t5 0.228
R1679 HB.n24 HB.t0 0.228
R1680 HB.n11 HB.t13 0.20525
R1681 HB.n11 HB.t14 0.20525
R1682 HB.n13 HB.t11 0.20525
R1683 HB.n13 HB.t12 0.20525
R1684 HB.n15 HB.t9 0.20525
R1685 HB.n15 HB.t10 0.20525
R1686 HB.n14 HB.n12 0.189974
R1687 HB.n34 HB.n29 0.1205
R1688 HB.n17 HB.n16 0.0952368
R1689 HB.n17 HB.n14 0.0952368
R1690 HB.n21 HB.n20 0.0952368
R1691 HB.n9 HB.n4 0.0785
R1692 HB HB.n35 0.0396304
R1693 HB.n26 HB.n25 0.0241842
R1694 H.n6 H.t17 142.148
R1695 H.n1 H.t25 113.632
R1696 H.n30 H.t18 113.632
R1697 H.n24 H.t28 113.632
R1698 H.n2 H.t24 109.174
R1699 H.n3 H.t23 109.174
R1700 H.n0 H.t22 109.174
R1701 H.n32 H.t20 109.174
R1702 H.n33 H.t21 109.174
R1703 H.n31 H.t19 109.174
R1704 H.n25 H.t27 109.174
R1705 H.n26 H.t26 109.174
R1706 H.n5 H.n0 18.5179
R1707 H.n34 H.n33 18.5179
R1708 H.n4 H.n3 18.4942
R1709 H.n32 H.n29 18.4942
R1710 H.n27 H.n26 18.4942
R1711 H.n10 H.n9 17.7266
R1712 H.n6 H.n5 16.7679
R1713 H.n28 H.n27 16.1533
R1714 H.n11 H.t4 15.3418
R1715 H.n35 H.n34 14.3418
R1716 H.n10 H.n6 13.657
R1717 H.n15 H.n14 13.0309
R1718 H.n3 H.n2 11.6805
R1719 H.n3 H.n0 11.6805
R1720 H.n32 H.n31 11.6805
R1721 H.n33 H.n32 11.6805
R1722 H.n26 H.n25 11.6805
R1723 H.n23 H.n22 9.70485
R1724 H.n4 H.n1 7.17687
R1725 H.n30 H.n29 7.17687
R1726 H.n27 H.n24 7.17687
R1727 H.n17 H.t16 5.7796
R1728 H.n21 H.t9 5.7796
R1729 H.n13 H.t3 5.73764
R1730 H.n8 H.t6 5.73764
R1731 H.n14 H.t0 5.6429
R1732 H.n9 H.t7 5.6429
R1733 H.n17 H.n16 5.38537
R1734 H.n19 H.n18 5.38537
R1735 H.n21 H.n20 5.38537
R1736 H.n13 H.n12 5.32067
R1737 H.n8 H.n7 5.32067
R1738 H.n2 H.n1 4.42851
R1739 H.n31 H.n30 4.42851
R1740 H.n25 H.n24 4.42851
R1741 H.n28 H.n23 2.97441
R1742 H.n11 H.n10 2.73963
R1743 H.n23 H.n15 1.17441
R1744 H.n35 H.n28 0.587457
R1745 H.n15 H.n11 0.391804
R1746 H.n12 H.t1 0.228
R1747 H.n12 H.t2 0.228
R1748 H.n7 H.t5 0.228
R1749 H.n7 H.t8 0.228
R1750 H.n16 H.t14 0.20525
R1751 H.n16 H.t15 0.20525
R1752 H.n18 H.t12 0.20525
R1753 H.n18 H.t13 0.20525
R1754 H.n20 H.t10 0.20525
R1755 H.n20 H.t11 0.20525
R1756 H.n19 H.n17 0.189974
R1757 H.n22 H.n21 0.0952368
R1758 H.n22 H.n19 0.0952368
R1759 H.n14 H.n13 0.0952368
R1760 H.n9 H.n8 0.0952368
R1761 H.n5 H.n4 0.0785
R1762 H.n34 H.n29 0.0785
R1763 H H.n35 0.0396304
R1764 XP.t43 XP.n25 127.788
R1765 XP.t32 XP.n10 127.788
R1766 XP.t34 XP.n7 127.668
R1767 XP.n25 XP.t42 127.668
R1768 XP.n24 XP.t41 127.668
R1769 XP.n23 XP.t40 127.668
R1770 XP.n22 XP.t39 127.668
R1771 XP.n21 XP.t38 127.668
R1772 XP.n20 XP.t37 127.668
R1773 XP.t36 XP.n8 127.668
R1774 XP.n35 XP.t35 127.668
R1775 XP.n10 XP.t33 127.668
R1776 XP.n26 XP.t43 113.632
R1777 XP.n11 XP.t32 113.632
R1778 XP.n1 XP.t53 113.632
R1779 XP.n38 XP.t54 113.632
R1780 XP.n62 XP.t45 113.632
R1781 XP.n65 XP.t49 113.632
R1782 XP.n38 XP.t55 113.603
R1783 XP.n62 XP.t44 113.603
R1784 XP.n13 XP.t34 109.174
R1785 XP.t42 XP.n19 109.174
R1786 XP.n28 XP.t41 109.174
R1787 XP.n29 XP.t40 109.174
R1788 XP.n30 XP.t39 109.174
R1789 XP.n31 XP.t38 109.174
R1790 XP.n32 XP.t37 109.174
R1791 XP.n33 XP.t36 109.174
R1792 XP.t35 XP.n34 109.174
R1793 XP.t33 XP.n9 109.174
R1794 XP.n2 XP.t52 109.174
R1795 XP.n3 XP.t51 109.174
R1796 XP.n4 XP.t50 109.174
R1797 XP.n66 XP.t48 109.174
R1798 XP.n67 XP.t47 109.174
R1799 XP.n64 XP.t46 109.174
R1800 XP.n39 XP.n38 26.8696
R1801 XP.n63 XP.n62 22.8718
R1802 XP.n37 XP.n5 20.2802
R1803 XP.n69 XP.n64 18.5179
R1804 XP.n13 XP.n12 18.4942
R1805 XP.n28 XP.n27 18.4942
R1806 XP.n29 XP.n18 18.4942
R1807 XP.n30 XP.n17 18.4942
R1808 XP.n31 XP.n16 18.4942
R1809 XP.n32 XP.n15 18.4942
R1810 XP.n33 XP.n14 18.4942
R1811 XP.n34 XP.n6 18.4942
R1812 XP.n3 XP.n0 18.4942
R1813 XP.n5 XP.n4 18.4942
R1814 XP.n68 XP.n67 18.4942
R1815 XP.n49 XP.n48 16.6309
R1816 XP.n70 XP.n69 14.8896
R1817 XP.n80 XP.n79 14.2831
R1818 XP.n47 XP.n46 14.2831
R1819 XP.n61 XP.n60 11.7396
R1820 XP.n29 XP.n28 11.6805
R1821 XP.n28 XP.n19 11.6805
R1822 XP.n30 XP.n29 11.6805
R1823 XP.n31 XP.n30 11.6805
R1824 XP.n32 XP.n31 11.6805
R1825 XP.n33 XP.n32 11.6805
R1826 XP.n34 XP.n33 11.6805
R1827 XP.n34 XP.n13 11.6805
R1828 XP.n13 XP.n9 11.6805
R1829 XP.n3 XP.n2 11.6805
R1830 XP.n4 XP.n3 11.6805
R1831 XP.n67 XP.n66 11.6805
R1832 XP.n67 XP.n64 11.6805
R1833 XP.n36 XP.n6 10.8396
R1834 XP.n36 XP.n35 9.0005
R1835 XP.n27 XP.n26 7.17687
R1836 XP.n12 XP.n11 7.17687
R1837 XP.n1 XP.n0 7.17687
R1838 XP.n68 XP.n65 7.17687
R1839 XP.n37 XP.n36 6.94615
R1840 XP.n51 XP.t21 5.7796
R1841 XP.n57 XP.t25 5.7796
R1842 XP.n72 XP.t13 5.73764
R1843 XP.n41 XP.t14 5.73764
R1844 XP.n45 XP.t2 5.73764
R1845 XP.n48 XP.t19 5.66659
R1846 XP.n48 XP.t23 5.61922
R1847 XP.n79 XP.t4 5.57185
R1848 XP.n51 XP.n50 5.38537
R1849 XP.n53 XP.n52 5.38537
R1850 XP.n55 XP.n54 5.38537
R1851 XP.n59 XP.n58 5.38537
R1852 XP.n57 XP.n56 5.38537
R1853 XP.n41 XP.n40 5.32067
R1854 XP.n43 XP.n42 5.32067
R1855 XP.n45 XP.n44 5.32067
R1856 XP.n72 XP.n71 5.32067
R1857 XP.n74 XP.n73 5.32067
R1858 XP.n76 XP.n75 5.32067
R1859 XP.n78 XP.n77 5.32067
R1860 XP.n26 XP.n19 4.42851
R1861 XP.n11 XP.n9 4.42851
R1862 XP.n2 XP.n1 4.42851
R1863 XP.n66 XP.n65 4.42851
R1864 XP.n39 XP.n37 3.71789
R1865 XP.n61 XP.n49 3.13093
R1866 XP.n49 XP.n47 1.76137
R1867 XP.n47 XP.n39 1.72224
R1868 XP.n80 XP.n70 1.33093
R1869 XP.n63 XP.n61 1.01789
R1870 XP.n70 XP.n63 0.391804
R1871 XP.n40 XP.t16 0.228
R1872 XP.n40 XP.t17 0.228
R1873 XP.n42 XP.t15 0.228
R1874 XP.n42 XP.t0 0.228
R1875 XP.n44 XP.t3 0.228
R1876 XP.n44 XP.t1 0.228
R1877 XP.n71 XP.t11 0.228
R1878 XP.n71 XP.t12 0.228
R1879 XP.n73 XP.t9 0.228
R1880 XP.n73 XP.t10 0.228
R1881 XP.n75 XP.t7 0.228
R1882 XP.n75 XP.t8 0.228
R1883 XP.n77 XP.t5 0.228
R1884 XP.n77 XP.t6 0.228
R1885 XP.n50 XP.t30 0.20525
R1886 XP.n50 XP.t29 0.20525
R1887 XP.n52 XP.t28 0.20525
R1888 XP.n52 XP.t31 0.20525
R1889 XP.n54 XP.t24 0.20525
R1890 XP.n54 XP.t26 0.20525
R1891 XP.n58 XP.t18 0.20525
R1892 XP.n58 XP.t20 0.20525
R1893 XP.n56 XP.t27 0.20525
R1894 XP.n56 XP.t22 0.20525
R1895 XP.n78 XP.n76 0.189974
R1896 XP.n76 XP.n74 0.189974
R1897 XP.n74 XP.n72 0.189974
R1898 XP.n43 XP.n41 0.189974
R1899 XP.n59 XP.n57 0.189974
R1900 XP.n55 XP.n53 0.189974
R1901 XP.n53 XP.n51 0.189974
R1902 XP.n79 XP.n78 0.166289
R1903 XP.n10 XP.n7 0.1205
R1904 XP.n25 XP.n24 0.1205
R1905 XP.n24 XP.n23 0.1205
R1906 XP.n23 XP.n22 0.1205
R1907 XP.n22 XP.n21 0.1205
R1908 XP.n21 XP.n20 0.1205
R1909 XP.n20 XP.n8 0.1205
R1910 XP.n27 XP.n18 0.1205
R1911 XP.n18 XP.n17 0.1205
R1912 XP.n17 XP.n16 0.1205
R1913 XP.n16 XP.n15 0.1205
R1914 XP.n15 XP.n14 0.1205
R1915 XP.n5 XP.n0 0.1205
R1916 XP.n12 XP.n6 0.1085
R1917 XP.n35 XP.n7 0.1085
R1918 XP.n35 XP.n8 0.1085
R1919 XP.n14 XP.n6 0.1085
R1920 XP.n46 XP.n45 0.0952368
R1921 XP.n46 XP.n43 0.0952368
R1922 XP.n60 XP.n59 0.0952368
R1923 XP.n60 XP.n55 0.0952368
R1924 XP.n69 XP.n68 0.0785
R1925 XP XP.n80 0.0396304
R1926 XN.t43 XN.n60 127.788
R1927 XN.t32 XN.n45 127.788
R1928 XN.t34 XN.n42 127.668
R1929 XN.n60 XN.t42 127.668
R1930 XN.n59 XN.t41 127.668
R1931 XN.n58 XN.t40 127.668
R1932 XN.n57 XN.t39 127.668
R1933 XN.n56 XN.t38 127.668
R1934 XN.n55 XN.t37 127.668
R1935 XN.t36 XN.n43 127.668
R1936 XN.n70 XN.t35 127.668
R1937 XN.n45 XN.t33 127.668
R1938 XN.n16 XN.t44 113.632
R1939 XN.n10 XN.t46 113.632
R1940 XN.n61 XN.t43 113.632
R1941 XN.n46 XN.t32 113.632
R1942 XN.n39 XN.t51 113.632
R1943 XN.n74 XN.t55 113.632
R1944 XN.n16 XN.t45 113.603
R1945 XN.n39 XN.t50 113.603
R1946 XN.n12 XN.t48 109.174
R1947 XN.n13 XN.t49 109.174
R1948 XN.n11 XN.t47 109.174
R1949 XN.n48 XN.t34 109.174
R1950 XN.t42 XN.n54 109.174
R1951 XN.n63 XN.t41 109.174
R1952 XN.n64 XN.t40 109.174
R1953 XN.n65 XN.t39 109.174
R1954 XN.n66 XN.t38 109.174
R1955 XN.n67 XN.t37 109.174
R1956 XN.n68 XN.t36 109.174
R1957 XN.t35 XN.n69 109.174
R1958 XN.t33 XN.n44 109.174
R1959 XN.n75 XN.t54 109.174
R1960 XN.n76 XN.t53 109.174
R1961 XN.n73 XN.t52 109.174
R1962 XN.n40 XN.n39 26.5957
R1963 XN.n17 XN.n16 23.1457
R1964 XN.n79 XN.n78 19.3114
R1965 XN.n14 XN.n13 18.5179
R1966 XN.n78 XN.n73 18.5179
R1967 XN.n12 XN.n9 18.4942
R1968 XN.n48 XN.n47 18.4942
R1969 XN.n63 XN.n62 18.4942
R1970 XN.n64 XN.n53 18.4942
R1971 XN.n65 XN.n52 18.4942
R1972 XN.n66 XN.n51 18.4942
R1973 XN.n67 XN.n50 18.4942
R1974 XN.n68 XN.n49 18.4942
R1975 XN.n69 XN.n41 18.4942
R1976 XN.n77 XN.n76 18.4942
R1977 XN.n31 XN.n30 16.357
R1978 XN.n15 XN.n8 15.2222
R1979 XN.n15 XN.n14 14.6157
R1980 XN.n38 XN.n37 12.757
R1981 XN.n29 XN.n28 12.0135
R1982 XN.n12 XN.n11 11.6805
R1983 XN.n13 XN.n12 11.6805
R1984 XN.n64 XN.n63 11.6805
R1985 XN.n63 XN.n54 11.6805
R1986 XN.n65 XN.n64 11.6805
R1987 XN.n66 XN.n65 11.6805
R1988 XN.n67 XN.n66 11.6805
R1989 XN.n68 XN.n67 11.6805
R1990 XN.n69 XN.n68 11.6805
R1991 XN.n69 XN.n48 11.6805
R1992 XN.n48 XN.n44 11.6805
R1993 XN.n76 XN.n75 11.6805
R1994 XN.n76 XN.n73 11.6805
R1995 XN.n71 XN.n41 10.8396
R1996 XN.n71 XN.n70 9.0005
R1997 XN.n72 XN.n71 7.22007
R1998 XN.n10 XN.n9 7.17687
R1999 XN.n62 XN.n61 7.17687
R2000 XN.n47 XN.n46 7.17687
R2001 XN.n77 XN.n74 7.17687
R2002 XN.n19 XN.t31 5.7796
R2003 XN.n25 XN.t20 5.7796
R2004 XN.n1 XN.t0 5.73764
R2005 XN.n30 XN.t19 5.73764
R2006 XN.n8 XN.t9 5.6429
R2007 XN.n30 XN.t18 5.54817
R2008 XN.n37 XN.n32 5.51014
R2009 XN.n36 XN.n34 5.51014
R2010 XN.n19 XN.n18 5.38537
R2011 XN.n21 XN.n20 5.38537
R2012 XN.n23 XN.n22 5.38537
R2013 XN.n27 XN.n26 5.38537
R2014 XN.n25 XN.n24 5.38537
R2015 XN.n7 XN.n6 5.32067
R2016 XN.n5 XN.n4 5.32067
R2017 XN.n3 XN.n2 5.32067
R2018 XN.n1 XN.n0 5.32067
R2019 XN.n37 XN.n33 5.32067
R2020 XN.n36 XN.n35 5.32067
R2021 XN.n11 XN.n10 4.42851
R2022 XN.n61 XN.n54 4.42851
R2023 XN.n46 XN.n44 4.42851
R2024 XN.n75 XN.n74 4.42851
R2025 XN.n72 XN.n40 2.93528
R2026 XN.n31 XN.n29 2.93528
R2027 XN.n40 XN.n38 1.72224
R2028 XN.n38 XN.n31 1.64398
R2029 XN.n29 XN.n17 1.33093
R2030 XN.n79 XN.n72 0.783109
R2031 XN.n17 XN.n15 0.391804
R2032 XN.n6 XN.t7 0.228
R2033 XN.n6 XN.t8 0.228
R2034 XN.n4 XN.t5 0.228
R2035 XN.n4 XN.t6 0.228
R2036 XN.n2 XN.t3 0.228
R2037 XN.n2 XN.t4 0.228
R2038 XN.n0 XN.t1 0.228
R2039 XN.n0 XN.t2 0.228
R2040 XN.n32 XN.t16 0.228
R2041 XN.n32 XN.t17 0.228
R2042 XN.n33 XN.t14 0.228
R2043 XN.n33 XN.t15 0.228
R2044 XN.n35 XN.t12 0.228
R2045 XN.n35 XN.t13 0.228
R2046 XN.n34 XN.t10 0.228
R2047 XN.n34 XN.t11 0.228
R2048 XN.n18 XN.t29 0.20525
R2049 XN.n18 XN.t30 0.20525
R2050 XN.n20 XN.t27 0.20525
R2051 XN.n20 XN.t28 0.20525
R2052 XN.n22 XN.t25 0.20525
R2053 XN.n22 XN.t26 0.20525
R2054 XN.n26 XN.t23 0.20525
R2055 XN.n26 XN.t24 0.20525
R2056 XN.n24 XN.t21 0.20525
R2057 XN.n24 XN.t22 0.20525
R2058 XN.n27 XN.n25 0.189974
R2059 XN.n23 XN.n21 0.189974
R2060 XN.n21 XN.n19 0.189974
R2061 XN.n3 XN.n1 0.189974
R2062 XN.n5 XN.n3 0.189974
R2063 XN.n7 XN.n5 0.189974
R2064 XN.n37 XN.n36 0.189974
R2065 XN.n45 XN.n42 0.1205
R2066 XN.n60 XN.n59 0.1205
R2067 XN.n59 XN.n58 0.1205
R2068 XN.n58 XN.n57 0.1205
R2069 XN.n57 XN.n56 0.1205
R2070 XN.n56 XN.n55 0.1205
R2071 XN.n55 XN.n43 0.1205
R2072 XN.n62 XN.n53 0.1205
R2073 XN.n53 XN.n52 0.1205
R2074 XN.n52 XN.n51 0.1205
R2075 XN.n51 XN.n50 0.1205
R2076 XN.n50 XN.n49 0.1205
R2077 XN.n47 XN.n41 0.1085
R2078 XN.n70 XN.n42 0.1085
R2079 XN.n70 XN.n43 0.1085
R2080 XN.n49 XN.n41 0.1085
R2081 XN.n28 XN.n27 0.0952368
R2082 XN.n28 XN.n23 0.0952368
R2083 XN.n8 XN.n7 0.0952368
R2084 XN.n14 XN.n9 0.0785
R2085 XN.n78 XN.n77 0.0785
R2086 XN XN.n79 0.0396304
C0 VDD NIP 6.70406f
C1 OUTN REGEN_CLKB 0.02948f
C2 H INP 0.01013f
C3 HB DP 0.75819f
C4 H DN 0.66623f
C5 INN NTAIL 1.55309f
C6 SENSE_CLK NIN 2.60237f
C7 NIN XN 14.5465f
C8 NIP XP 14.4614f
C9 VDD HB 16.1006f
C10 SENSE_CLK H 1.23646f
C11 H XN 1.91259f
C12 NIP SENSE_BOOST_CLK 0.21857f
C13 INP INN 4.39106f
C14 SENSE_CLK DP 0.29923f
C15 VDD DN 6.18388f
C16 HB XP 3.58406f
C17 SENSE_BOOST_CLK NTAIL 5.37348f
C18 SENSE_CLK INN 5.46787f
C19 VDD SENSE_CLK 21.2686f
C20 DN XP 0.04432f
C21 VDD XN 25.3962f
C22 HB OUTN 1.39766f
C23 INP SENSE_BOOST_CLK 0.07703f
C24 SENSE_CLK XP 5.70356f
C25 NIP NTAIL 10.1886f
C26 XN XP 22.8576f
C27 VDD CAPTURE_CLK 0.11494f
C28 H NIN 0.07808f
C29 HB NIP 0.07069f
C30 SENSE_CLK SENSE_BOOST_CLK 6.47808f
C31 NIP INP 1.58284f
C32 H DP 2.1383f
C33 NIN INN 2.30328f
C34 INP NTAIL 2.27268f
C35 VDD NIN 6.7829f
C36 SENSE_CLK NIP 2.64521f
C37 H OUTP 1.28169f
C38 H INN 0.01013f
C39 NIP XN 2.86849f
C40 HB DN 2.12721f
C41 VDD H 16.7985f
C42 SENSE_CLK NTAIL 1.32172f
C43 NIN XP 2.21087f
C44 SENSE_CLK HB 2.31435f
C45 VDD DP 6.18171f
C46 HB XN 0.56886f
C47 H XP 0.82467f
C48 NIN SENSE_BOOST_CLK 0.0301f
C49 VDD OUTP 5.18923f
C50 SENSE_CLK INP 0.40197f
C51 SENSE_CLK DN 0.18071f
C52 CAPTURE_CLKB VDD 0.11029f
C53 DP XP 2.21809f
C54 DN XN 2.15469f
C55 REGEN_CLK VDD 0.13916f
C56 SENSE_CLK XN 5.09008f
C57 VDD XP 25.819f
C58 VDD REGEN_CLKB 0.13321f
C59 H NIP 0.07683f
C60 INN SENSE_BOOST_CLK 0.07735f
C61 NIN NTAIL 10.6347f
C62 VDD OUTN 5.28554f
C63 HB NIN 0.07207f
C64 REGEN_CLK OUTN 0.01097f
C65 H HB 7.51355f
C66 CAPTURE_CLK VSS 0.14352f
C67 CAPTURE_CLKB VSS 0.14766f
C68 REGEN_CLK VSS 0.10547f
C69 REGEN_CLKB VSS 0.09145f
C70 SENSE_BOOST_CLK VSS 19.08508f
C71 INN VSS 9.46523f
C72 INP VSS 9.94744f
C73 OUTN VSS 7.39491f
C74 OUTP VSS 7.49786f
C75 SENSE_CLK VSS 17.67546f
C76 VDD VSS 1.39227p
C77 NTAIL VSS 46.98668f
C78 DN VSS 9.84723f
C79 DP VSS 9.85739f
C80 NIN VSS 3.76356f
C81 NIP VSS 3.47617f
C82 HB VSS 19.64067f
C83 H VSS 20.30146f
C84 XP VSS 10.75778f
C85 XN VSS 11.15447f
C86 XN.t9 VSS 1.40085f
C87 XN.t0 VSS 1.40913f
C88 XN.t2 VSS 0.30031f
C89 XN.t1 VSS 0.30031f
C90 XN.n0 VSS 1.06449f
C91 XN.n1 VSS 0.58512f
C92 XN.t4 VSS 0.30031f
C93 XN.t3 VSS 0.30031f
C94 XN.n2 VSS 1.06449f
C95 XN.n3 VSS 0.30545f
C96 XN.t6 VSS 0.30031f
C97 XN.t5 VSS 0.30031f
C98 XN.n4 VSS 1.06449f
C99 XN.n5 VSS 0.30545f
C100 XN.t8 VSS 0.30031f
C101 XN.t7 VSS 0.30031f
C102 XN.n6 VSS 1.06449f
C103 XN.n7 VSS 0.24533f
C104 XN.n8 VSS 1.66511f
C105 XN.n9 VSS 0.32954f
C106 XN.n10 VSS 0.16803f
C107 XN.n11 VSS 0.18011f
C108 XN.n12 VSS 0.18011f
C109 XN.n13 VSS 0.17033f
C110 XN.n14 VSS 0.3775f
C111 XN.n15 VSS 2.16471f
C112 XN.n16 VSS 0.9973f
C113 XN.n17 VSS 1.42665f
C114 XN.t31 VSS 1.43937f
C115 XN.t30 VSS 0.33222f
C116 XN.t29 VSS 0.33222f
C117 XN.n18 VSS 1.05664f
C118 XN.n19 VSS 0.59551f
C119 XN.t28 VSS 0.33222f
C120 XN.t27 VSS 0.33222f
C121 XN.n20 VSS 1.05664f
C122 XN.n21 VSS 0.31329f
C123 XN.t26 VSS 0.33222f
C124 XN.t25 VSS 0.33222f
C125 XN.n22 VSS 1.05664f
C126 XN.n23 VSS 0.25318f
C127 XN.t20 VSS 1.43937f
C128 XN.t22 VSS 0.33222f
C129 XN.t21 VSS 0.33222f
C130 XN.n24 VSS 1.05664f
C131 XN.n25 VSS 0.59551f
C132 XN.t24 VSS 0.33222f
C133 XN.t23 VSS 0.33222f
C134 XN.n26 VSS 1.05664f
C135 XN.n27 VSS 0.25318f
C136 XN.n28 VSS 0.85518f
C137 XN.n29 VSS 1.72642f
C138 XN.t19 VSS 1.48871f
C139 XN.t18 VSS 1.47912f
C140 XN.n30 VSS 2.31351f
C141 XN.n31 VSS 2.80884f
C142 XN.t17 VSS 0.30288f
C143 XN.t16 VSS 0.30031f
C144 XN.n32 VSS 1.07282f
C145 XN.t15 VSS 0.30031f
C146 XN.t14 VSS 0.30031f
C147 XN.n33 VSS 1.06449f
C148 XN.t11 VSS 0.30031f
C149 XN.t10 VSS 0.30289f
C150 XN.n34 VSS 1.07282f
C151 XN.t13 VSS 0.30031f
C152 XN.t12 VSS 0.30031f
C153 XN.n35 VSS 1.06449f
C154 XN.n36 VSS 0.53944f
C155 XN.n37 VSS 1.44722f
C156 XN.n38 VSS 1.69004f
C157 XN.n39 VSS 1.44329f
C158 XN.n40 VSS 3.21788f
C159 XN.n41 VSS 0.24424f
C160 XN.n42 VSS 0.25216f
C161 XN.n43 VSS 0.25216f
C162 XN.n44 VSS 0.18011f
C163 XN.n45 VSS 0.49868f
C164 XN.n46 VSS 0.16803f
C165 XN.n47 VSS 0.33968f
C166 XN.n48 VSS 0.18011f
C167 XN.n49 VSS 0.11653f
C168 XN.n50 VSS 0.11679f
C169 XN.n51 VSS 0.11679f
C170 XN.n52 VSS 0.11679f
C171 XN.n53 VSS 0.11679f
C172 XN.n54 VSS 0.18011f
C173 XN.n55 VSS 0.25242f
C174 XN.n56 VSS 0.25242f
C175 XN.n57 VSS 0.25242f
C176 XN.n58 VSS 0.25242f
C177 XN.n59 VSS 0.25242f
C178 XN.n60 VSS 0.49868f
C179 XN.n61 VSS 0.16803f
C180 XN.n62 VSS 0.33994f
C181 XN.n63 VSS 0.18011f
C182 XN.n64 VSS 0.18011f
C183 XN.n65 VSS 0.18011f
C184 XN.n66 VSS 0.18011f
C185 XN.n67 VSS 0.18011f
C186 XN.n68 VSS 0.18011f
C187 XN.n69 VSS 0.18011f
C188 XN.n70 VSS 0.29791f
C189 XN.n71 VSS 1.89723f
C190 XN.n72 VSS 1.11528f
C191 XN.n73 VSS 0.17033f
C192 XN.n74 VSS 0.16803f
C193 XN.n75 VSS 0.18011f
C194 XN.n76 VSS 0.18011f
C195 XN.n77 VSS 0.32954f
C196 XN.n78 VSS 1.2398f
C197 XN.n79 VSS 1.90891f
C198 XP.n0 VSS 0.33737f
C199 XP.n1 VSS 0.16675f
C200 XP.n2 VSS 0.17874f
C201 XP.n3 VSS 0.17874f
C202 XP.n4 VSS 0.16893f
C203 XP.n5 VSS 1.42089f
C204 XP.n6 VSS 0.24239f
C205 XP.n7 VSS 0.25025f
C206 XP.n8 VSS 0.25025f
C207 XP.n9 VSS 0.17874f
C208 XP.n10 VSS 0.4949f
C209 XP.n11 VSS 0.16675f
C210 XP.n12 VSS 0.3371f
C211 XP.n13 VSS 0.17874f
C212 XP.n14 VSS 0.11565f
C213 XP.n15 VSS 0.11591f
C214 XP.n16 VSS 0.11591f
C215 XP.n17 VSS 0.11591f
C216 XP.n18 VSS 0.11591f
C217 XP.n19 VSS 0.17874f
C218 XP.n20 VSS 0.25051f
C219 XP.n21 VSS 0.25051f
C220 XP.n22 VSS 0.25051f
C221 XP.n23 VSS 0.25051f
C222 XP.n24 VSS 0.25051f
C223 XP.n25 VSS 0.4949f
C224 XP.n26 VSS 0.16675f
C225 XP.n27 VSS 0.33737f
C226 XP.n28 VSS 0.17874f
C227 XP.n29 VSS 0.17874f
C228 XP.n30 VSS 0.17874f
C229 XP.n31 VSS 0.17874f
C230 XP.n32 VSS 0.17874f
C231 XP.n33 VSS 0.17874f
C232 XP.n34 VSS 0.17874f
C233 XP.n35 VSS 0.29566f
C234 XP.n36 VSS 1.795f
C235 XP.n37 VSS 3.10172f
C236 XP.n38 VSS 1.47542f
C237 XP.n39 VSS 3.45737f
C238 XP.t14 VSS 1.39919f
C239 XP.t17 VSS 0.29876f
C240 XP.t16 VSS 0.29876f
C241 XP.n40 VSS 1.05643f
C242 XP.n41 VSS 0.58069f
C243 XP.t0 VSS 0.29876f
C244 XP.t15 VSS 0.29876f
C245 XP.n42 VSS 1.05643f
C246 XP.n43 VSS 0.24348f
C247 XP.t2 VSS 1.3992f
C248 XP.t1 VSS 0.29876f
C249 XP.t3 VSS 0.29876f
C250 XP.n44 VSS 1.05643f
C251 XP.n45 VSS 0.52103f
C252 XP.n46 VSS 1.37228f
C253 XP.n47 VSS 2.05638f
C254 XP.t23 VSS 1.47329f
C255 XP.t19 VSS 1.47571f
C256 XP.n48 VSS 2.36091f
C257 XP.n49 VSS 2.92298f
C258 XP.t21 VSS 1.43044f
C259 XP.t29 VSS 0.33163f
C260 XP.t30 VSS 0.33163f
C261 XP.n50 VSS 1.04864f
C262 XP.n51 VSS 0.591f
C263 XP.t31 VSS 0.33163f
C264 XP.t28 VSS 0.33163f
C265 XP.n52 VSS 1.04864f
C266 XP.n53 VSS 0.31092f
C267 XP.t26 VSS 0.33163f
C268 XP.t24 VSS 0.33163f
C269 XP.n54 VSS 1.04864f
C270 XP.n55 VSS 0.25126f
C271 XP.t25 VSS 1.43044f
C272 XP.t22 VSS 0.33163f
C273 XP.t27 VSS 0.33163f
C274 XP.n56 VSS 1.04864f
C275 XP.n57 VSS 0.591f
C276 XP.t20 VSS 0.33163f
C277 XP.t18 VSS 0.33163f
C278 XP.n58 VSS 1.04864f
C279 XP.n59 VSS 0.25126f
C280 XP.n60 VSS 0.78552f
C281 XP.n61 VSS 1.62307f
C282 XP.n62 VSS 0.95385f
C283 XP.n63 VSS 1.25315f
C284 XP.n64 VSS 0.16904f
C285 XP.n65 VSS 0.16675f
C286 XP.n66 VSS 0.17874f
C287 XP.n67 VSS 0.17874f
C288 XP.n68 VSS 0.32704f
C289 XP.n69 VSS 0.42062f
C290 XP.n70 VSS 0.87173f
C291 XP.t13 VSS 1.3992f
C292 XP.t12 VSS 0.29876f
C293 XP.t11 VSS 0.29876f
C294 XP.n71 VSS 1.05643f
C295 XP.n72 VSS 0.58069f
C296 XP.t10 VSS 0.29876f
C297 XP.t9 VSS 0.29876f
C298 XP.n73 VSS 1.05643f
C299 XP.n74 VSS 0.30313f
C300 XP.t8 VSS 0.29876f
C301 XP.t7 VSS 0.29876f
C302 XP.n75 VSS 1.05643f
C303 XP.n76 VSS 0.30313f
C304 XP.t6 VSS 0.29876f
C305 XP.t5 VSS 0.29876f
C306 XP.n77 VSS 1.05643f
C307 XP.n78 VSS 0.28822f
C308 XP.t4 VSS 1.38791f
C309 XP.n79 VSS 1.55413f
C310 XP.n80 VSS 1.56891f
C311 H.n0 VSS 0.11342f
C312 H.n1 VSS 0.11189f
C313 H.n2 VSS 0.11993f
C314 H.n3 VSS 0.11993f
C315 H.n4 VSS 0.21944f
C316 H.n5 VSS 0.44107f
C317 H.n6 VSS 3.43312f
C318 H.t6 VSS 1.04841f
C319 H.t8 VSS 0.31176f
C320 H.t5 VSS 0.31176f
C321 H.n7 VSS 0.70885f
C322 H.n8 VSS 0.3496f
C323 H.t7 VSS 1.04796f
C324 H.n9 VSS 1.60381f
C325 H.n10 VSS 3.91167f
C326 H.t4 VSS 1.22975f
C327 H.n11 VSS 0.73537f
C328 H.t3 VSS 0.99928f
C329 H.t2 VSS 0.26026f
C330 H.t1 VSS 0.26026f
C331 H.n12 VSS 0.70885f
C332 H.n13 VSS 0.3496f
C333 H.t0 VSS 0.99312f
C334 H.n14 VSS 0.87696f
C335 H.n15 VSS 0.88918f
C336 H.t16 VSS 0.94461f
C337 H.t15 VSS 0.20773f
C338 H.t14 VSS 0.20773f
C339 H.n16 VSS 0.70362f
C340 H.n17 VSS 0.39655f
C341 H.t13 VSS 0.20773f
C342 H.t12 VSS 0.20773f
C343 H.n18 VSS 0.70362f
C344 H.n19 VSS 0.1686f
C345 H.t9 VSS 0.94461f
C346 H.t11 VSS 0.20773f
C347 H.t10 VSS 0.20773f
C348 H.n20 VSS 0.70362f
C349 H.n21 VSS 0.35652f
C350 H.n22 VSS 0.2121f
C351 H.n23 VSS 0.7741f
C352 H.n24 VSS 0.11189f
C353 H.n25 VSS 0.11993f
C354 H.n26 VSS 0.11335f
C355 H.n27 VSS 0.64427f
C356 H.n28 VSS 1.08568f
C357 H.n29 VSS 0.21944f
C358 H.n30 VSS 0.11189f
C359 H.n31 VSS 0.11993f
C360 H.n32 VSS 0.11993f
C361 H.n33 VSS 0.11342f
C362 H.n34 VSS 0.22097f
C363 H.n35 VSS 0.30698f
C364 HB.n0 VSS 0.11853f
C365 HB.n1 VSS 0.12705f
C366 HB.n2 VSS 0.12008f
C367 HB.n3 VSS 0.67097f
C368 HB.n4 VSS 0.23246f
C369 HB.n5 VSS 0.11853f
C370 HB.n6 VSS 0.12705f
C371 HB.n7 VSS 0.12705f
C372 HB.n8 VSS 0.12015f
C373 HB.n9 VSS 0.2663f
C374 HB.n10 VSS 1.55603f
C375 HB.t15 VSS 0.99499f
C376 HB.t14 VSS 0.21453f
C377 HB.t13 VSS 0.21453f
C378 HB.n11 VSS 0.74539f
C379 HB.n12 VSS 0.42009f
C380 HB.t12 VSS 0.21453f
C381 HB.t11 VSS 0.21453f
C382 HB.n13 VSS 0.74539f
C383 HB.n14 VSS 0.1786f
C384 HB.t8 VSS 0.995f
C385 HB.t10 VSS 0.21453f
C386 HB.t9 VSS 0.21453f
C387 HB.n15 VSS 0.74539f
C388 HB.n16 VSS 0.37768f
C389 HB.n17 VSS 0.17978f
C390 HB.n18 VSS 0.85854f
C391 HB.t16 VSS 1.04186f
C392 HB.t4 VSS 0.26148f
C393 HB.t1 VSS 0.26148f
C394 HB.n19 VSS 0.75093f
C395 HB.n20 VSS 0.37035f
C396 HB.t2 VSS 1.04006f
C397 HB.n21 VSS 0.88409f
C398 HB.n22 VSS 0.92912f
C399 HB.t7 VSS 1.31404f
C400 HB.n23 VSS 0.72746f
C401 HB.t3 VSS 1.09781f
C402 HB.t6 VSS 1.10226f
C403 HB.t0 VSS 0.31856f
C404 HB.t5 VSS 0.31856f
C405 HB.n24 VSS 0.75093f
C406 HB.n25 VSS 0.33855f
C407 HB.n26 VSS 1.68299f
C408 HB.n27 VSS 3.98342f
C409 HB.n28 VSS 3.12935f
C410 HB.n29 VSS 0.2398f
C411 HB.n30 VSS 0.11853f
C412 HB.n31 VSS 0.12705f
C413 HB.n32 VSS 0.12705f
C414 HB.n33 VSS 0.12008f
C415 HB.n34 VSS 0.4592f
C416 HB.n35 VSS 0.70771f
C417 NIP.t16 VSS 1.58999f
C418 NIP.t15 VSS 0.30371f
C419 NIP.t14 VSS 0.30371f
C420 NIP.n0 VSS 1.22977f
C421 NIP.n1 VSS 0.69308f
C422 NIP.t13 VSS 0.30371f
C423 NIP.t12 VSS 0.30371f
C424 NIP.n2 VSS 1.22977f
C425 NIP.n3 VSS 0.29467f
C426 NIP.t9 VSS 1.59f
C427 NIP.t11 VSS 0.30371f
C428 NIP.t10 VSS 0.30371f
C429 NIP.n4 VSS 1.22977f
C430 NIP.n5 VSS 0.62312f
C431 NIP.n6 VSS 1.25236f
C432 NIP.t3 VSS 1.65659f
C433 NIP.t2 VSS 0.36909f
C434 NIP.t1 VSS 0.36909f
C435 NIP.n7 VSS 1.23891f
C436 NIP.n8 VSS 0.61102f
C437 NIP.t0 VSS 1.65244f
C438 NIP.n9 VSS 3.48061f
C439 NIP.n10 VSS 5.1674f
C440 NIP.t6 VSS 0.37035f
C441 NIP.t21 VSS 0.36688f
C442 NIP.n11 VSS 1.23967f
C443 NIP.t22 VSS 0.36688f
C444 NIP.t23 VSS 0.36688f
C445 NIP.n12 VSS 1.22977f
C446 NIP.n13 VSS 0.6459f
C447 NIP.t20 VSS 0.36688f
C448 NIP.t18 VSS 0.36688f
C449 NIP.n14 VSS 1.22977f
C450 NIP.t19 VSS 0.36688f
C451 NIP.t17 VSS 0.37035f
C452 NIP.n15 VSS 1.23967f
C453 NIP.t4 VSS 0.36688f
C454 NIP.t7 VSS 0.36688f
C455 NIP.n16 VSS 1.22977f
C456 NIP.n17 VSS 0.6459f
C457 NIP.t8 VSS 0.36688f
C458 NIP.t5 VSS 0.36688f
C459 NIP.n18 VSS 1.22977f
C460 NIP.n19 VSS 0.36463f
C461 NIP.n20 VSS 0.93417f
C462 NIP.n21 VSS 0.86596f
C463 NIN.t17 VSS 0.37276f
C464 NIN.t18 VSS 0.36932f
C465 NIN.n0 VSS 1.25728f
C466 NIN.t6 VSS 0.36932f
C467 NIN.t7 VSS 0.36932f
C468 NIN.n1 VSS 1.24724f
C469 NIN.n2 VSS 0.65507f
C470 NIN.t23 VSS 0.36932f
C471 NIN.t8 VSS 0.36932f
C472 NIN.n3 VSS 1.24724f
C473 NIN.t19 VSS 0.36932f
C474 NIN.t5 VSS 0.37276f
C475 NIN.n4 VSS 1.25728f
C476 NIN.t20 VSS 0.36932f
C477 NIN.t22 VSS 0.36932f
C478 NIN.n5 VSS 1.24724f
C479 NIN.n6 VSS 0.65507f
C480 NIN.t21 VSS 0.36932f
C481 NIN.t0 VSS 0.36932f
C482 NIN.n7 VSS 1.24724f
C483 NIN.n8 VSS 0.36981f
C484 NIN.n9 VSS 1.00904f
C485 NIN.t4 VSS 1.67828f
C486 NIN.t3 VSS 0.37249f
C487 NIN.t2 VSS 0.37249f
C488 NIN.n10 VSS 1.25651f
C489 NIN.n11 VSS 0.61971f
C490 NIN.t1 VSS 1.67404f
C491 NIN.n12 VSS 3.4549f
C492 NIN.n13 VSS 4.91382f
C493 NIN.t16 VSS 1.64548f
C494 NIN.t15 VSS 0.34005f
C495 NIN.t14 VSS 0.34005f
C496 NIN.n14 VSS 1.24724f
C497 NIN.n15 VSS 0.70293f
C498 NIN.t13 VSS 0.34005f
C499 NIN.t12 VSS 0.34005f
C500 NIN.n16 VSS 1.24724f
C501 NIN.n17 VSS 0.29885f
C502 NIN.t9 VSS 1.64547f
C503 NIN.t11 VSS 0.34005f
C504 NIN.t10 VSS 0.34005f
C505 NIN.n18 VSS 1.24724f
C506 NIN.n19 VSS 0.63197f
C507 NIN.n20 VSS 0.98797f
C508 NIN.n21 VSS 1.39363f
C509 DP.t3 VSS 0.89965f
C510 DP.t4 VSS 0.90102f
C511 DP.n0 VSS 0.60387f
C512 DP.t0 VSS 0.90157f
C513 DP.t5 VSS 0.28762f
C514 DP.t1 VSS 0.28762f
C515 DP.n1 VSS 0.59078f
C516 DP.n2 VSS 0.32473f
C517 DP.t2 VSS 0.89959f
C518 DP.n3 VSS 1.08581f
C519 DP.n4 VSS 1.42483f
C520 DP.n5 VSS 0.34607f
C521 DP.n6 VSS 0.09111f
C522 DP.n7 VSS 0.06482f
C523 DP.n8 VSS 0.09996f
C524 DP.n9 VSS 0.06482f
C525 DP.n10 VSS 0.09996f
C526 DP.n11 VSS 0.13994f
C527 DP.n12 VSS 0.14009f
C528 DP.n13 VSS 0.14009f
C529 DP.n14 VSS 0.14009f
C530 DP.n15 VSS 0.27676f
C531 DP.n16 VSS 0.09325f
C532 DP.n17 VSS 0.18866f
C533 DP.n18 VSS 0.09996f
C534 DP.n19 VSS 0.09996f
C535 DP.n20 VSS 0.09996f
C536 DP.n21 VSS 0.09996f
C537 DP.n22 VSS 0.06467f
C538 DP.n23 VSS 0.15109f
C539 DP.n24 VSS 0.54719f
C540 DP.n25 VSS 0.24004f
C541 DN.n0 VSS 0.33878f
C542 DN.n1 VSS 0.0894f
C543 DN.n2 VSS 0.0636f
C544 DN.n3 VSS 0.09808f
C545 DN.n4 VSS 0.0636f
C546 DN.n5 VSS 0.09808f
C547 DN.n6 VSS 0.13732f
C548 DN.n7 VSS 0.13746f
C549 DN.n8 VSS 0.13746f
C550 DN.n9 VSS 0.13746f
C551 DN.n10 VSS 0.27157f
C552 DN.n11 VSS 0.0915f
C553 DN.n12 VSS 0.18512f
C554 DN.n13 VSS 0.09808f
C555 DN.n14 VSS 0.09808f
C556 DN.n15 VSS 0.09808f
C557 DN.n16 VSS 0.09808f
C558 DN.n17 VSS 0.06346f
C559 DN.n18 VSS 0.14833f
C560 DN.n19 VSS 0.61121f
C561 DN.t2 VSS 0.88923f
C562 DN.t1 VSS 0.2868f
C563 DN.t0 VSS 0.2868f
C564 DN.n20 VSS 0.57969f
C565 DN.n21 VSS 0.31864f
C566 DN.t3 VSS 0.88738f
C567 DN.n22 VSS 0.98658f
C568 DN.n23 VSS 1.34081f
C569 DN.t5 VSS 0.8912f
C570 DN.t4 VSS 0.88596f
C571 DN.n24 VSS 0.52459f
C572 DN.n25 VSS 0.3408f
C573 NTAIL.t44 VSS 1.01642f
C574 NTAIL.t43 VSS 0.20524f
C575 NTAIL.t42 VSS 0.20524f
C576 NTAIL.n0 VSS 0.7709f
C577 NTAIL.n1 VSS 0.36115f
C578 NTAIL.t41 VSS 0.20524f
C579 NTAIL.t40 VSS 0.20524f
C580 NTAIL.n2 VSS 0.7709f
C581 NTAIL.n3 VSS 0.18974f
C582 NTAIL.t39 VSS 0.20524f
C583 NTAIL.t38 VSS 0.20524f
C584 NTAIL.n4 VSS 0.7709f
C585 NTAIL.n5 VSS 0.18974f
C586 NTAIL.t37 VSS 0.20524f
C587 NTAIL.t36 VSS 0.20524f
C588 NTAIL.n6 VSS 0.7709f
C589 NTAIL.n7 VSS 0.18974f
C590 NTAIL.t35 VSS 0.20524f
C591 NTAIL.t34 VSS 0.20524f
C592 NTAIL.n8 VSS 0.7709f
C593 NTAIL.n9 VSS 0.18974f
C594 NTAIL.t33 VSS 0.20524f
C595 NTAIL.t32 VSS 0.20524f
C596 NTAIL.n10 VSS 0.7709f
C597 NTAIL.n11 VSS 0.15485f
C598 NTAIL.t21 VSS 1.01642f
C599 NTAIL.t23 VSS 0.20524f
C600 NTAIL.t22 VSS 0.20524f
C601 NTAIL.n12 VSS 0.7709f
C602 NTAIL.n13 VSS 0.36115f
C603 NTAIL.t25 VSS 0.20524f
C604 NTAIL.t24 VSS 0.20524f
C605 NTAIL.n14 VSS 0.7709f
C606 NTAIL.n15 VSS 0.18974f
C607 NTAIL.t27 VSS 0.20524f
C608 NTAIL.t26 VSS 0.20524f
C609 NTAIL.n16 VSS 0.7709f
C610 NTAIL.n17 VSS 0.18974f
C611 NTAIL.t29 VSS 0.20524f
C612 NTAIL.t28 VSS 0.20524f
C613 NTAIL.n18 VSS 0.7709f
C614 NTAIL.n19 VSS 0.18974f
C615 NTAIL.t31 VSS 0.20524f
C616 NTAIL.t30 VSS 0.20524f
C617 NTAIL.n20 VSS 0.7709f
C618 NTAIL.n21 VSS 0.15485f
C619 NTAIL.n22 VSS 0.27405f
C620 NTAIL.t10 VSS 0.21934f
C621 NTAIL.t6 VSS 0.2167f
C622 NTAIL.n23 VSS 0.61838f
C623 NTAIL.t11 VSS 0.2167f
C624 NTAIL.t7 VSS 0.2167f
C625 NTAIL.n24 VSS 0.61345f
C626 NTAIL.t9 VSS 0.2167f
C627 NTAIL.t8 VSS 0.21933f
C628 NTAIL.n25 VSS 0.61838f
C629 NTAIL.t5 VSS 0.2167f
C630 NTAIL.t12 VSS 0.2167f
C631 NTAIL.n26 VSS 0.61345f
C632 NTAIL.n27 VSS 0.32219f
C633 NTAIL.n28 VSS 0.68023f
C634 NTAIL.n29 VSS 1.60812f
C635 NTAIL.t4 VSS 0.31216f
C636 NTAIL.t3 VSS 0.30981f
C637 NTAIL.n30 VSS 0.77602f
C638 NTAIL.t2 VSS 0.30981f
C639 NTAIL.t1 VSS 0.30981f
C640 NTAIL.n31 VSS 0.7709f
C641 NTAIL.n32 VSS 0.28537f
C642 NTAIL.t0 VSS 1.11798f
C643 NTAIL.n33 VSS 0.25093f
C644 NTAIL.n34 VSS 0.44781f
C645 NTAIL.t15 VSS 0.18551f
C646 NTAIL.t18 VSS 0.18376f
C647 NTAIL.n35 VSS 0.61838f
C648 NTAIL.t17 VSS 0.18376f
C649 NTAIL.t16 VSS 0.18376f
C650 NTAIL.n36 VSS 0.61345f
C651 NTAIL.t14 VSS 0.18376f
C652 NTAIL.t13 VSS 0.18551f
C653 NTAIL.n37 VSS 0.61838f
C654 NTAIL.t20 VSS 0.18376f
C655 NTAIL.t19 VSS 0.18376f
C656 NTAIL.n38 VSS 0.61345f
C657 NTAIL.n39 VSS 0.32219f
C658 NTAIL.n40 VSS 0.68023f
C659 NTAIL.n41 VSS 0.4795f
C660 VSS.t79 VSS 0.07134f
C661 VSS.t92 VSS 0.06945f
C662 VSS.t98 VSS 0.06945f
C663 VSS.t29 VSS 0.07134f
C664 VSS.t102 VSS 0.06945f
C665 VSS.t96 VSS 0.06945f
C666 VSS.t100 VSS 0.06945f
C667 VSS.t94 VSS 0.06945f
C668 VSS.t151 VSS 0.05718f
C669 VSS.t149 VSS 0.056f
C670 VSS.t147 VSS 0.056f
C671 VSS.t119 VSS 0.056f
C672 VSS.t145 VSS 0.056f
C673 VSS.t143 VSS 0.056f
C674 VSS.t141 VSS 0.056f
C675 VSS.t140 VSS 0.056f
C676 VSS.t82 VSS 0.17816f
C677 VSS.t77 VSS 0.17813f
C678 VSS.t8 VSS 0.16292f
C679 VSS.t12 VSS 0.16057f
C680 VSS.t10 VSS 0.16057f
C681 VSS.t16 VSS 0.16057f
C682 VSS.t14 VSS 0.16057f
C683 VSS.t38 VSS 0.17678f
C684 VSS.t45 VSS 0.17682f
C685 VSS.t70 VSS 0.11864f
C686 VSS.t72 VSS 0.11641f
C687 VSS.t86 VSS 0.11641f
C688 VSS.t88 VSS 0.11641f
C689 VSS.t23 VSS 0.07078f
C690 VSS.t48 VSS 0.07271f
C691 VSS.t33 VSS 0.07078f
C692 VSS.t21 VSS 0.07078f
C693 VSS.t1 VSS 0.07078f
C694 VSS.t19 VSS 0.07078f
C695 VSS.t31 VSS 0.0727f
C696 VSS.t3 VSS 0.07078f
C697 VSS.t75 VSS 0.15863f
C698 VSS.t113 VSS 0.056f
C699 VSS.t111 VSS 0.05718f
C700 VSS.t117 VSS 0.056f
C701 VSS.t115 VSS 0.056f
C702 VSS.t121 VSS 0.056f
C703 VSS.t109 VSS 0.056f
C704 VSS.t125 VSS 0.056f
C705 VSS.t123 VSS 0.056f
C706 VSS.t107 VSS 0.056f
C707 VSS.t127 VSS 0.056f
C708 VSS.t131 VSS 0.056f
C709 VSS.t129 VSS 0.056f
C710 VSS.t135 VSS 0.056f
C711 VSS.t133 VSS 0.056f
C712 VSS.t137 VSS 0.056f
C713 VSS.t139 VSS 0.056f
C714 VSS.t105 VSS 0.14369f
C715 VSS.t36 VSS 0.12568f
C716 VSS.t41 VSS 0.12332f
C717 VSS.t43 VSS 0.12332f
C718 VSS.t5 VSS 0.12332f
C719 VDD.n0 VSS 0.21632f
C720 VDD.n1 VSS 0.19651f
C721 VDD.n2 VSS 0.08832f
C722 VDD.n3 VSS 0.10083f
C723 VDD.n4 VSS 0.09645f
C724 VDD.t2 VSS 0.64297f
C725 VDD.n5 VSS 0.09645f
C726 VDD.n6 VSS 0.10083f
C727 VDD.n7 VSS 0.10279f
C728 VDD.n8 VSS 0.10083f
C729 VDD.n9 VSS 0.09645f
C730 VDD.t114 VSS 1.80031f
C731 VDD.n10 VSS 0.27255f
C732 VDD.t88 VSS 0.51437f
C733 VDD.n11 VSS 0.09645f
C734 VDD.n12 VSS 0.10083f
C735 VDD.n13 VSS 0.10279f
C736 VDD.n14 VSS 0.10083f
C737 VDD.n15 VSS 0.09645f
C738 VDD.t110 VSS 0.64297f
C739 VDD.n16 VSS 0.09645f
C740 VDD.n17 VSS 0.10083f
C741 VDD.n18 VSS 0.10279f
C742 VDD.n19 VSS 0.10083f
C743 VDD.n20 VSS 0.09645f
C744 VDD.t68 VSS 0.90016f
C745 VDD.n21 VSS 0.43773f
C746 VDD.n22 VSS 5.70727f
C747 VDD.n23 VSS 0.09645f
C748 VDD.n24 VSS 0.10083f
C749 VDD.n25 VSS 0.08628f
C750 VDD.n26 VSS 0.10083f
C751 VDD.n27 VSS 0.09645f
C752 VDD.n28 VSS 4.92212f
C753 VDD.n29 VSS 3.71018f
C754 VDD.n30 VSS 4.50078f
C755 VDD.t100 VSS 2.57187f
C756 VDD.t94 VSS 0.51437f
C757 VDD.t78 VSS 0.64297f
C758 VDD.n31 VSS 3.60062f
C759 VDD.n32 VSS 0.09645f
C760 VDD.n33 VSS 0.10083f
C761 VDD.n34 VSS 0.27827f
C762 VDD.n35 VSS 0.10279f
C763 VDD.n36 VSS 0.10279f
C764 VDD.n37 VSS 0.10083f
C765 VDD.n38 VSS 0.09645f
C766 VDD.n39 VSS 4.75797f
C767 VDD.t130 VSS 1.80031f
C768 VDD.t112 VSS 0.51437f
C769 VDD.t80 VSS 0.51437f
C770 VDD.t96 VSS 1.15734f
C771 VDD.n40 VSS 1.02875f
C772 VDD.t60 VSS 0.38578f
C773 VDD.t8 VSS 0.51437f
C774 VDD.t64 VSS 0.51437f
C775 VDD.t10 VSS 0.51437f
C776 VDD.t58 VSS 0.38578f
C777 VDD.t92 VSS 0.25719f
C778 VDD.t12 VSS 0.25719f
C779 VDD.t76 VSS 0.25719f
C780 VDD.t70 VSS 0.25719f
C781 VDD.t86 VSS 0.25719f
C782 VDD.t66 VSS 0.25719f
C783 VDD.t108 VSS 0.25719f
C784 VDD.t62 VSS 0.25719f
C785 VDD.n41 VSS 0.43493f
C786 VDD.n42 VSS 0.27255f
C787 VDD.n43 VSS 0.27255f
C788 VDD.n44 VSS 2.23524f
C789 VDD.t52 VSS 1.80031f
C790 VDD.t54 VSS 0.51437f
C791 VDD.t56 VSS 0.51437f
C792 VDD.t14 VSS 0.51437f
C793 VDD.n45 VSS 2.44328f
C794 VDD.t124 VSS 2.44328f
C795 VDD.t120 VSS 0.51437f
C796 VDD.t4 VSS 0.51437f
C797 VDD.t104 VSS 0.51437f
C798 VDD.n46 VSS 1.02875f
C799 VDD.n47 VSS 0.09645f
C800 VDD.n48 VSS 0.10083f
C801 VDD.n49 VSS 0.10279f
C802 VDD.n50 VSS 0.10279f
C803 VDD.n51 VSS 0.10279f
C804 VDD.n52 VSS 0.10083f
C805 VDD.n53 VSS 0.09645f
C806 VDD.n54 VSS 0.25719f
C807 VDD.t128 VSS 2.31469f
C808 VDD.t51 VSS 2.44328f
C809 VDD.t50 VSS 0.51437f
C810 VDD.t49 VSS 0.51437f
C811 VDD.t48 VSS 0.38578f
C812 VDD.n55 VSS 0.25719f
C813 VDD.t47 VSS 0.38578f
C814 VDD.t46 VSS 0.51437f
C815 VDD.t45 VSS 0.51437f
C816 VDD.t44 VSS 2.44328f
C817 VDD.t106 VSS 2.31469f
C818 VDD.t72 VSS 0.51437f
C819 VDD.t90 VSS 0.51437f
C820 VDD.t74 VSS 2.44328f
C821 VDD.n56 VSS 2.44328f
C822 VDD.t36 VSS 0.51437f
C823 VDD.t38 VSS 0.51437f
C824 VDD.t40 VSS 0.51437f
C825 VDD.t42 VSS 1.80031f
C826 VDD.n57 VSS 2.23524f
C827 VDD.t84 VSS 0.64297f
C828 VDD.n58 VSS 0.25719f
C829 VDD.n59 VSS 0.09645f
C830 VDD.n60 VSS 0.10083f
C831 VDD.n61 VSS 0.10279f
C832 VDD.n62 VSS 0.10279f
C833 VDD.n63 VSS 0.10279f
C834 VDD.n64 VSS 0.10083f
C835 VDD.n65 VSS 0.09645f
C836 VDD.n66 VSS 1.02875f
C837 VDD.t34 VSS 0.90016f
C838 VDD.t6 VSS 0.25719f
C839 VDD.t32 VSS 0.25719f
C840 VDD.t116 VSS 0.25719f
C841 VDD.t30 VSS 0.25719f
C842 VDD.t82 VSS 0.25719f
C843 VDD.t28 VSS 0.25719f
C844 VDD.t98 VSS 0.25719f
C845 VDD.t26 VSS 0.25719f
C846 VDD.t126 VSS 0.51437f
C847 VDD.t122 VSS 0.51437f
C848 VDD.t0 VSS 1.15734f
C849 VDD.n67 VSS 1.02875f
C850 VDD.t20 VSS 0.38578f
C851 VDD.t16 VSS 0.51437f
C852 VDD.t18 VSS 0.51437f
C853 VDD.t22 VSS 0.51437f
C854 VDD.t24 VSS 0.38578f
C855 VDD.n68 VSS 0.43493f
C856 VDD.n69 VSS 0.27255f
C857 VDD.n70 VSS 0.27255f
C858 VDD.t118 VSS 0.51437f
C859 VDD.t102 VSS 2.57187f
C860 VDD.n71 VSS 5.70727f
C861 VDD.n72 VSS 4.75797f
C862 VDD.n73 VSS 0.09645f
C863 VDD.n74 VSS 0.10083f
C864 VDD.n75 VSS 0.10279f
C865 VDD.n76 VSS 0.10279f
C866 VDD.n77 VSS 0.10279f
C867 VDD.n78 VSS 0.10083f
C868 VDD.n79 VSS 0.09645f
C869 VDD.n80 VSS 3.60062f
C870 VDD.n81 VSS 4.50078f
C871 VDD.n82 VSS 3.69744f
C872 VDD.n83 VSS 4.91605f
C873 VDD.n84 VSS 0.0819f
C874 VDD.n85 VSS 0.10717f
C875 VDD.n86 VSS 0.15431f
C876 VDD.t7 VSS 0.18463f
C877 VDD.t117 VSS 0.18463f
C878 VDD.n87 VSS 0.05769f
C879 VDD.t83 VSS 0.18463f
C880 VDD.t99 VSS 0.18796f
C881 VDD.n88 VSS 0.05814f
C882 VDD.n89 VSS 0.15388f
C883 VDD.n90 VSS 0.2294f
C884 VDD.n91 VSS 0.15431f
C885 VDD.t111 VSS 0.18796f
C886 VDD.t129 VSS 0.18793f
C887 VDD.n92 VSS 0.12736f
C888 VDD.n93 VSS 0.17294f
C889 VDD.n94 VSS 0.15431f
C890 VDD.t109 VSS 0.18931f
C891 VDD.t87 VSS 0.18596f
C892 VDD.n95 VSS 0.05792f
C893 VDD.t77 VSS 0.18596f
C894 VDD.t93 VSS 0.18596f
C895 VDD.n96 VSS 0.05781f
C896 VDD.n97 VSS 0.15398f
C897 VDD.n98 VSS 0.20954f
C898 VDD.t95 VSS 0.13446f
C899 VDD.t101 VSS 0.13683f
C900 VDD.n99 VSS 0.05814f
C901 VDD.t79 VSS 0.1939f
C902 VDD.n100 VSS 0.16993f
C903 VDD.n101 VSS 0.71628f
C904 VDD.t131 VSS 0.12755f
C905 VDD.t113 VSS 0.12755f
C906 VDD.n102 VSS 0.05769f
C907 VDD.t81 VSS 0.12755f
C908 VDD.t97 VSS 0.12979f
C909 VDD.n103 VSS 0.05814f
C910 VDD.n104 VSS 0.15388f
C911 VDD.n105 VSS 0.26754f
C912 VDD.t13 VSS 0.10581f
C913 VDD.t69 VSS 0.10838f
C914 VDD.n106 VSS 0.05814f
C915 VDD.t67 VSS 0.10581f
C916 VDD.t71 VSS 0.10581f
C917 VDD.n107 VSS 0.05769f
C918 VDD.n108 VSS 0.02923f
C919 VDD.t59 VSS 0.10581f
C920 VDD.t63 VSS 0.10581f
C921 VDD.n109 VSS 0.05769f
C922 VDD.n110 VSS 0.01655f
C923 VDD.t65 VSS 0.10581f
C924 VDD.t11 VSS 0.10581f
C925 VDD.n111 VSS 0.05769f
C926 VDD.n112 VSS 0.01655f
C927 VDD.t61 VSS 0.10581f
C928 VDD.t9 VSS 0.10581f
C929 VDD.n113 VSS 0.05769f
C930 VDD.n114 VSS 0.23728f
C931 VDD.n115 VSS 0.17835f
C932 VDD.n116 VSS 0.09208f
C933 VDD.n117 VSS 0.51877f
C934 VDD.n118 VSS 0.15431f
C935 VDD.n119 VSS 0.02572f
C936 VDD.t121 VSS 0.18463f
C937 VDD.t125 VSS 0.18796f
C938 VDD.n120 VSS 0.05814f
C939 VDD.t105 VSS 0.18463f
C940 VDD.t5 VSS 0.18463f
C941 VDD.n121 VSS 0.05769f
C942 VDD.n122 VSS 0.10225f
C943 VDD.n123 VSS 0.14669f
C944 VDD.n124 VSS 0.07073f
C945 VDD.t15 VSS 0.1409f
C946 VDD.t57 VSS 0.1409f
C947 VDD.n125 VSS 0.05769f
C948 VDD.t55 VSS 0.1409f
C949 VDD.t53 VSS 0.14338f
C950 VDD.n126 VSS 0.05814f
C951 VDD.n127 VSS 0.1243f
C952 VDD.n128 VSS 0.17565f
C953 VDD.n129 VSS 0.07073f
C954 VDD.n130 VSS 0.15431f
C955 VDD.n131 VSS 0.15431f
C956 VDD.n132 VSS 0.10287f
C957 VDD.t107 VSS 0.18928f
C958 VDD.t85 VSS 0.18931f
C959 VDD.n133 VSS 0.12513f
C960 VDD.n134 VSS 0.17192f
C961 VDD.n135 VSS 0.05787f
C962 VDD.t43 VSS 0.1409f
C963 VDD.t41 VSS 0.1409f
C964 VDD.n136 VSS 0.05769f
C965 VDD.t39 VSS 0.1409f
C966 VDD.t37 VSS 0.14338f
C967 VDD.n137 VSS 0.05814f
C968 VDD.n138 VSS 0.1243f
C969 VDD.n139 VSS 0.1705f
C970 VDD.t75 VSS 0.18596f
C971 VDD.t91 VSS 0.18596f
C972 VDD.n140 VSS 0.05769f
C973 VDD.t73 VSS 0.18596f
C974 VDD.t89 VSS 0.18931f
C975 VDD.n141 VSS 0.05814f
C976 VDD.n142 VSS 0.09473f
C977 VDD.n143 VSS 0.13835f
C978 VDD.t17 VSS 0.10581f
C979 VDD.t21 VSS 0.10581f
C980 VDD.n144 VSS 0.05814f
C981 VDD.t23 VSS 0.10581f
C982 VDD.t19 VSS 0.10581f
C983 VDD.n145 VSS 0.05769f
C984 VDD.n146 VSS 0.02923f
C985 VDD.t27 VSS 0.10581f
C986 VDD.t25 VSS 0.10581f
C987 VDD.n147 VSS 0.05769f
C988 VDD.n148 VSS 0.01655f
C989 VDD.t31 VSS 0.10581f
C990 VDD.t29 VSS 0.10581f
C991 VDD.n149 VSS 0.05769f
C992 VDD.n150 VSS 0.01655f
C993 VDD.t35 VSS 0.10838f
C994 VDD.t33 VSS 0.10581f
C995 VDD.n151 VSS 0.05769f
C996 VDD.n152 VSS 0.22501f
C997 VDD.n153 VSS 0.1625f
C998 VDD.n154 VSS 0.05191f
C999 VDD.n155 VSS 0.15431f
C1000 VDD.n156 VSS 0.15431f
C1001 VDD.n157 VSS 0.0643f
C1002 VDD.t1 VSS 0.13683f
C1003 VDD.t123 VSS 0.13446f
C1004 VDD.n158 VSS 0.05769f
C1005 VDD.t127 VSS 0.13446f
C1006 VDD.t115 VSS 0.13446f
C1007 VDD.n159 VSS 0.05814f
C1008 VDD.n160 VSS 0.15388f
C1009 VDD.n161 VSS 0.20522f
C1010 VDD.n162 VSS 0.13374f
C1011 VDD.t119 VSS 0.12755f
C1012 VDD.t3 VSS 0.12979f
C1013 VDD.n163 VSS 0.05814f
C1014 VDD.t103 VSS 0.18699f
C1015 VDD.n164 VSS 0.16081f
C1016 VDD.n165 VSS 0.20572f
C1017 VDD.n166 VSS 0.0913f
C1018 VDD.n167 VSS 0.15431f
C1019 VDD.n168 VSS 0.14788f
C1020 VDD.n169 VSS 0.10612f
C1021 VDD.n170 VSS 0.03004f
C1022 SENSE_CLK.n0 VSS 0.48214f
C1023 SENSE_CLK.n1 VSS 0.08669f
C1024 SENSE_CLK.n2 VSS 0.13368f
C1025 SENSE_CLK.n3 VSS 0.18735f
C1026 SENSE_CLK.n4 VSS 0.13368f
C1027 SENSE_CLK.n5 VSS 0.08669f
C1028 SENSE_CLK.n6 VSS 0.08669f
C1029 SENSE_CLK.n7 VSS 0.13368f
C1030 SENSE_CLK.n8 VSS 0.37013f
C1031 SENSE_CLK.n9 VSS 0.13368f
C1032 SENSE_CLK.n10 VSS 0.12471f
C1033 SENSE_CLK.n11 VSS 0.25231f
C1034 SENSE_CLK.n12 VSS 0.13368f
C1035 SENSE_CLK.n13 VSS 0.18735f
C1036 SENSE_CLK.n14 VSS 0.18735f
C1037 SENSE_CLK.n15 VSS 0.18735f
C1038 SENSE_CLK.n16 VSS 0.13368f
C1039 SENSE_CLK.n17 VSS 0.08669f
C1040 SENSE_CLK.n18 VSS 0.08669f
C1041 SENSE_CLK.n19 VSS 0.08669f
C1042 SENSE_CLK.n20 VSS 0.13368f
C1043 SENSE_CLK.n21 VSS 0.18735f
C1044 SENSE_CLK.n22 VSS 0.18735f
C1045 SENSE_CLK.n23 VSS 0.18735f
C1046 SENSE_CLK.n24 VSS 0.13368f
C1047 SENSE_CLK.n25 VSS 0.12634f
C1048 SENSE_CLK.n26 VSS 0.32313f
C1049 SENSE_CLK.n27 VSS 3.59056f
C1050 SENSE_CLK.n28 VSS 0.12642f
C1051 SENSE_CLK.n29 VSS 0.12471f
C1052 SENSE_CLK.n30 VSS 0.13368f
C1053 SENSE_CLK.n31 VSS 0.13368f
C1054 SENSE_CLK.n32 VSS 0.24459f
C1055 SENSE_CLK.n33 VSS 1.7118f
C1056 SENSE_CLK.n34 VSS 5.33063f
C1057 SENSE_CLK.n35 VSS 0.46283f
C1058 SENSE_CLK.n36 VSS 0.12185f
C1059 SENSE_CLK.n37 VSS 0.08669f
C1060 SENSE_CLK.n38 VSS 0.13368f
C1061 SENSE_CLK.n39 VSS 0.08669f
C1062 SENSE_CLK.n40 VSS 0.13368f
C1063 SENSE_CLK.n41 VSS 0.18716f
C1064 SENSE_CLK.n42 VSS 0.18735f
C1065 SENSE_CLK.n43 VSS 0.18735f
C1066 SENSE_CLK.n44 VSS 0.18735f
C1067 SENSE_CLK.n45 VSS 0.37013f
C1068 SENSE_CLK.n46 VSS 0.12471f
C1069 SENSE_CLK.n47 VSS 0.25231f
C1070 SENSE_CLK.n48 VSS 0.13368f
C1071 SENSE_CLK.n49 VSS 0.13368f
C1072 SENSE_CLK.n50 VSS 0.13368f
C1073 SENSE_CLK.n51 VSS 0.13368f
C1074 SENSE_CLK.n52 VSS 0.08649f
C1075 SENSE_CLK.n53 VSS 0.20207f
C1076 SENSE_CLK.n54 VSS 3.08855f
C1077 SENSE_CLK.n55 VSS 2.11634f
C1078 SENSE_CLK.n56 VSS 0.06781f
C1079 SENSE_CLK.n57 VSS 0.15424f
C1080 SENSE_CLK.n58 VSS 0.14554f
C1081 SENSE_CLK.n59 VSS 0.25135f
C1082 SENSE_CLK.n60 VSS 0.15424f
C1083 SENSE_CLK.n61 VSS 0.15424f
C1084 SENSE_CLK.n62 VSS 0.14721f
C1085 SENSE_CLK.n63 VSS 0.28721f
C1086 SENSE_CLK.n64 VSS 0.92752f
C1087 SENSE_CLK.n65 VSS 0.12642f
C1088 SENSE_CLK.n66 VSS 0.12471f
C1089 SENSE_CLK.n67 VSS 0.13368f
C1090 SENSE_CLK.n68 VSS 0.13368f
C1091 SENSE_CLK.n69 VSS 0.24459f
C1092 SENSE_CLK.n70 VSS 1.7118f
C1093 SENSE_CLK.n71 VSS 3.57558f
C1094 SENSE_CLK.n72 VSS 0.39796f
C1095 SENSE_CLK.n73 VSS 0.08669f
C1096 SENSE_CLK.n74 VSS 0.08669f
C1097 SENSE_CLK.n75 VSS 0.08669f
C1098 SENSE_CLK.n76 VSS 0.08669f
C1099 SENSE_CLK.n77 VSS 0.08669f
C1100 SENSE_CLK.n78 VSS 0.08669f
C1101 SENSE_CLK.n79 VSS 0.25231f
C1102 SENSE_CLK.n80 VSS 0.18735f
C1103 SENSE_CLK.n81 VSS 0.18735f
C1104 SENSE_CLK.n82 VSS 0.18735f
C1105 SENSE_CLK.n83 VSS 0.18735f
C1106 SENSE_CLK.n84 VSS 0.18735f
C1107 SENSE_CLK.n85 VSS 0.18735f
C1108 SENSE_CLK.n86 VSS 0.18735f
C1109 SENSE_CLK.n87 VSS 0.37013f
C1110 SENSE_CLK.n88 VSS 0.12471f
C1111 SENSE_CLK.n89 VSS 0.13368f
C1112 SENSE_CLK.n90 VSS 0.13368f
C1113 SENSE_CLK.n91 VSS 0.13368f
C1114 SENSE_CLK.n92 VSS 0.13368f
C1115 SENSE_CLK.n93 VSS 0.13368f
C1116 SENSE_CLK.n94 VSS 0.13368f
C1117 SENSE_CLK.n95 VSS 0.13368f
C1118 SENSE_CLK.n96 VSS 0.13368f
C1119 SENSE_CLK.n97 VSS 0.12634f
C1120 SENSE_CLK.n98 VSS 0.23878f
C1121 SENSE_CLK.n99 VSS 3.09475f
C1122 SENSE_CLK.n100 VSS 4.35577f
C1123 OUTP.t1 VSS 0.22562f
C1124 OUTP.t4 VSS 0.22562f
C1125 OUTP.n0 VSS 0.56561f
C1126 OUTP.t0 VSS 0.81446f
C1127 OUTP.n1 VSS 0.52821f
C1128 OUTP.t2 VSS 0.81396f
C1129 OUTP.t3 VSS 0.22562f
C1130 OUTP.t5 VSS 0.22562f
C1131 OUTP.n2 VSS 0.56112f
C1132 OUTP.n3 VSS 0.28431f
C1133 OUTP.t6 VSS 0.8087f
C1134 OUTP.n4 VSS 0.38673f
C1135 OUTP.n5 VSS 1.28652f
C1136 OUTN.t3 VSS 0.84493f
C1137 OUTN.t5 VSS 0.23629f
C1138 OUTN.t6 VSS 0.23629f
C1139 OUTN.n0 VSS 0.58043f
C1140 OUTN.n1 VSS 0.2941f
C1141 OUTN.t0 VSS 0.83944f
C1142 OUTN.n2 VSS 0.44015f
C1143 OUTN.t1 VSS 0.23629f
C1144 OUTN.t2 VSS 0.23629f
C1145 OUTN.n3 VSS 0.58508f
C1146 OUTN.t4 VSS 0.84545f
C1147 OUTN.n4 VSS 0.50614f
C1148 OUTN.n5 VSS 1.34972f
C1149 INP.n0 VSS 0.31471f
C1150 INP.n1 VSS 0.08285f
C1151 INP.n2 VSS 0.05895f
C1152 INP.n3 VSS 0.0909f
C1153 INP.n4 VSS 0.0909f
C1154 INP.n5 VSS 0.1274f
C1155 INP.n6 VSS 0.05895f
C1156 INP.n7 VSS 0.17157f
C1157 INP.n8 VSS 0.25168f
C1158 INP.n9 VSS 0.0848f
C1159 INP.n10 VSS 0.0909f
C1160 INP.n11 VSS 0.0909f
C1161 INP.n12 VSS 0.0909f
C1162 INP.n13 VSS 0.1274f
C1163 INP.n14 VSS 0.1274f
C1164 INP.n15 VSS 0.12726f
C1165 INP.n16 VSS 0.0909f
C1166 INP.n17 VSS 0.05881f
C1167 INP.n18 VSS 0.1374f
C1168 INP.n19 VSS 3.00536f
C1169 INN.n0 VSS 0.47575f
C1170 INN.n1 VSS 0.08891f
C1171 INN.n2 VSS 0.13741f
C1172 INN.n3 VSS 0.19258f
C1173 INN.n4 VSS 0.08911f
C1174 INN.n5 VSS 0.08911f
C1175 INN.n6 VSS 0.25936f
C1176 INN.n7 VSS 0.38046f
C1177 INN.n8 VSS 0.1282f
C1178 INN.n9 VSS 0.13741f
C1179 INN.n10 VSS 0.13741f
C1180 INN.n11 VSS 0.13741f
C1181 INN.n12 VSS 0.19258f
C1182 INN.n13 VSS 0.19258f
C1183 INN.n14 VSS 0.19238f
C1184 INN.n15 VSS 0.13741f
C1185 INN.n16 VSS 0.13741f
C1186 INN.n17 VSS 0.12525f
C1187 INN.n18 VSS 0.20771f
C1188 INN.n19 VSS 4.81763f
C1189 SENSE_BOOST_CLK.n0 VSS 0.12585f
C1190 SENSE_BOOST_CLK.n1 VSS 0.04212f
C1191 SENSE_BOOST_CLK.n2 VSS 0.07511f
C1192 SENSE_BOOST_CLK.n3 VSS 0.10146f
C1193 SENSE_BOOST_CLK.n4 VSS 0.04222f
C1194 SENSE_BOOST_CLK.n5 VSS 0.04222f
C1195 SENSE_BOOST_CLK.n6 VSS 0.04222f
C1196 SENSE_BOOST_CLK.n7 VSS 0.04222f
C1197 SENSE_BOOST_CLK.n8 VSS 0.04222f
C1198 SENSE_BOOST_CLK.n9 VSS 0.04222f
C1199 SENSE_BOOST_CLK.n10 VSS 0.04222f
C1200 SENSE_BOOST_CLK.n11 VSS 0.04222f
C1201 SENSE_BOOST_CLK.n12 VSS 0.04222f
C1202 SENSE_BOOST_CLK.n13 VSS 0.04222f
C1203 SENSE_BOOST_CLK.n14 VSS 0.12288f
C1204 SENSE_BOOST_CLK.n15 VSS 0.10146f
C1205 SENSE_BOOST_CLK.n16 VSS 0.10146f
C1206 SENSE_BOOST_CLK.n17 VSS 0.10146f
C1207 SENSE_BOOST_CLK.n18 VSS 0.10146f
C1208 SENSE_BOOST_CLK.n19 VSS 0.10146f
C1209 SENSE_BOOST_CLK.n20 VSS 0.10146f
C1210 SENSE_BOOST_CLK.n21 VSS 0.10146f
C1211 SENSE_BOOST_CLK.n22 VSS 0.10146f
C1212 SENSE_BOOST_CLK.n23 VSS 0.20071f
C1213 SENSE_BOOST_CLK.n24 VSS 0.07088f
C1214 SENSE_BOOST_CLK.n25 VSS 0.07511f
C1215 SENSE_BOOST_CLK.n26 VSS 0.07511f
C1216 SENSE_BOOST_CLK.n27 VSS 0.07511f
C1217 SENSE_BOOST_CLK.n28 VSS 0.07511f
C1218 SENSE_BOOST_CLK.n29 VSS 0.07511f
C1219 SENSE_BOOST_CLK.n30 VSS 0.07511f
C1220 SENSE_BOOST_CLK.n31 VSS 0.07511f
C1221 SENSE_BOOST_CLK.n32 VSS 0.07511f
C1222 SENSE_BOOST_CLK.n33 VSS 0.07511f
C1223 SENSE_BOOST_CLK.n34 VSS 0.07511f
C1224 SENSE_BOOST_CLK.n35 VSS 0.07511f
C1225 SENSE_BOOST_CLK.n36 VSS 0.10146f
C1226 SENSE_BOOST_CLK.n37 VSS 0.10146f
C1227 SENSE_BOOST_CLK.n38 VSS 0.10137f
C1228 SENSE_BOOST_CLK.n39 VSS 0.07511f
C1229 SENSE_BOOST_CLK.n40 VSS 0.07511f
C1230 SENSE_BOOST_CLK.n41 VSS 0.04222f
C1231 SENSE_BOOST_CLK.n42 VSS 0.07511f
C1232 SENSE_BOOST_CLK.n43 VSS 0.10146f
C1233 SENSE_BOOST_CLK.n44 VSS 0.04222f
C1234 SENSE_BOOST_CLK.n45 VSS 0.04222f
C1235 SENSE_BOOST_CLK.n46 VSS 0.04222f
C1236 SENSE_BOOST_CLK.n47 VSS 0.04222f
C1237 SENSE_BOOST_CLK.n48 VSS 0.12288f
C1238 SENSE_BOOST_CLK.n49 VSS 0.10146f
C1239 SENSE_BOOST_CLK.n50 VSS 0.10146f
C1240 SENSE_BOOST_CLK.n51 VSS 0.10146f
C1241 SENSE_BOOST_CLK.n52 VSS 0.20071f
C1242 SENSE_BOOST_CLK.n53 VSS 0.07088f
C1243 SENSE_BOOST_CLK.n54 VSS 0.07511f
C1244 SENSE_BOOST_CLK.n55 VSS 0.07511f
C1245 SENSE_BOOST_CLK.n56 VSS 0.07511f
C1246 SENSE_BOOST_CLK.n57 VSS 0.07511f
C1247 SENSE_BOOST_CLK.n58 VSS 0.07511f
C1248 SENSE_BOOST_CLK.n59 VSS 0.07511f
C1249 SENSE_BOOST_CLK.n60 VSS 0.10146f
C1250 SENSE_BOOST_CLK.n61 VSS 0.10146f
C1251 SENSE_BOOST_CLK.n62 VSS 0.10137f
C1252 SENSE_BOOST_CLK.n63 VSS 0.07511f
C1253 SENSE_BOOST_CLK.n64 VSS 0.04212f
C1254 SENSE_BOOST_CLK.n65 VSS 0.07607f
C1255 SENSE_BOOST_CLK.n66 VSS 2.29248f
.ends
