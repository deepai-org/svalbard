* PEX produced using /foss/tools/sak/sak-pex.sh with m=3 and s=1 (extresist threshold=0 mOhm, minres=1 mOhm, mindelay=0 ps)
* NGSPICE file created from cml_to_cmos_pex.ext - technology: gf180mcuD

.subckt cml_to_cmos_pex INP INN SENSE_CLK REGEN_CLK REGEN_CLKB CAPTURE_CLK CAPTURE_CLKB
+ VDD VSS OUTP OUTN SENSE_BOOST_CLK
X0 VSS.t5 SENSE_CLK.t4 NTAIL.t0 VSS.t4 nfet_03v3 ad=2.6p pd=10.52u as=4.4p ps=20.88u w=10u l=0.28u
X1 DN.t2 XN.t48 VDD.t79 VDD.t78 pfet_03v3 ad=2.08p pd=8.52u as=2.08p ps=8.52u w=8u l=0.28u
X2 NTAIL.t28 SENSE_BOOST_CLK.t12 VSS.t112 VSS.t111 nfet_03v3 ad=2.6p pd=10.52u as=2.6p ps=10.52u w=10u l=0.28u
X3 VSS.t41 HB.t20 OUTN.t0 VSS.t40 nfet_03v3 ad=2.08p pd=8.52u as=3.52p ps=16.88u w=8u l=0.28u
X4 OUTN.t3 HB.t23 VDD.t117 VDD.t116 pfet_03v3 ad=2.08p pd=8.52u as=2.08p ps=8.52u w=8u l=0.28u
X5 VDD.t29 SENSE_CLK.t34 XP.t8 VDD.t28 pfet_03v3 ad=2.08p pd=8.52u as=2.08p ps=8.52u w=8u l=0.28u
X6 XP.t1 SENSE_CLK.t21 XN.t15 VDD.t49 pfet_03v3 ad=2.08p pd=8.52u as=2.08p ps=8.52u w=8u l=0.28u
X7 XN.t27 XP.t36 NIN.t11 VSS.t43 nfet_03v3 ad=2.08p pd=8.52u as=2.08p ps=8.52u w=8u l=0.28u
X8 NTAIL.t5 INP.t1 NIP.t22 VSS.t62 nfet_03v3 ad=2.08p pd=8.52u as=2.08p ps=8.52u w=8u l=0.28u
X9 NIP.t24 XN.t33 XP.t28 VSS.t65 nfet_03v3 ad=2.08p pd=8.52u as=2.08p ps=8.52u w=8u l=0.28u
X10 DN.t1 XN.t44 VSS.t15 VSS.t14 nfet_03v3 ad=3.52p pd=16.88u as=2.08p ps=8.52u w=8u l=0.28u
X11 VDD.t99 XN.t49 DN.t4 VDD.t98 pfet_03v3 ad=2.08p pd=8.52u as=3.52p ps=16.88u w=8u l=0.28u
X12 VDD.t113 HB.t24 OUTN.t2 VDD.t112 pfet_03v3 ad=2.08p pd=8.52u as=3.52p ps=16.88u w=8u l=0.28u
X13 NTAIL.t14 INP.t9 NIP.t14 VSS.t54 nfet_03v3 ad=2.08p pd=8.52u as=2.08p ps=8.52u w=8u l=0.28u
X14 XP.t9 SENSE_CLK.t33 VDD.t31 VDD.t30 pfet_03v3 ad=2.08p pd=8.52u as=2.08p ps=8.52u w=8u l=0.28u
X15 H.t5 HB.t25 VDD.t111 VDD.t110 pfet_03v3 ad=3.52p pd=16.88u as=2.08p ps=8.52u w=8u l=0.28u
X16 XP.t7 SENSE_CLK.t35 VDD.t27 VDD.t26 pfet_03v3 ad=2.08p pd=8.52u as=2.08p ps=8.52u w=8u l=0.28u
X17 NTAIL.t36 SENSE_BOOST_CLK.t4 VSS.t128 VSS.t127 nfet_03v3 ad=2.6p pd=10.52u as=2.6p ps=10.52u w=10u l=0.28u
X18 XP.t20 XN.t50 VDD.t77 VDD.t76 pfet_03v3 ad=3.52p pd=16.88u as=2.08p ps=8.52u w=8u l=0.28u
X19 NIN.t16 INN.t10 NTAIL.t51 VSS.t151 nfet_03v3 ad=2.08p pd=8.52u as=2.08p ps=8.52u w=8u l=0.28u
X20 VSS.t23 DN.t7 HB.t12 VSS.t22 nfet_03v3 ad=2.08p pd=8.52u as=2.08p ps=8.52u w=8u l=0.28u
X21 VDD.t61 SENSE_CLK.t12 XN.t2 VDD.t60 pfet_03v3 ad=2.08p pd=8.52u as=2.08p ps=8.52u w=8u l=0.28u
X22 VSS.t79 H.t19 OUTP.t6 VSS.t78 nfet_03v3 ad=2.08p pd=8.52u as=2.08p ps=8.52u w=8u l=0.28u
X23 VDD.t63 SENSE_CLK.t10 XN.t4 VDD.t62 pfet_03v3 ad=2.08p pd=8.52u as=2.08p ps=8.52u w=8u l=0.28u
X24 VDD.t1 H.t28 OUTP.t0 VDD.t0 pfet_03v3 ad=2.08p pd=8.52u as=3.52p ps=16.88u w=8u l=0.28u
X25 VSS.t132 SENSE_BOOST_CLK.t1 NTAIL.t39 VSS.t131 nfet_03v3 ad=2.6p pd=10.52u as=2.6p ps=10.52u w=10u l=0.28u
X26 NIP.t21 INP.t2 NTAIL.t8 VSS.t61 nfet_03v3 ad=2.08p pd=8.52u as=2.08p ps=8.52u w=8u l=0.28u
X27 VSS.t96 SENSE_BOOST_CLK.t23 NTAIL.t17 VSS.t95 nfet_03v3 ad=2.6p pd=10.52u as=4.4p ps=20.88u w=10u l=0.28u
X28 VDD.t103 XP.t53 HB.t5 VDD.t102 pfet_03v3 ad=2.08p pd=8.52u as=3.52p ps=16.88u w=8u l=0.28u
X29 NTAIL.t15 INP.t5 NIP.t18 VSS.t58 nfet_03v3 ad=2.08p pd=8.52u as=2.08p ps=8.52u w=8u l=0.28u
X30 HB.t11 DN.t8 VSS.t75 VSS.t74 nfet_03v3 ad=2.08p pd=8.52u as=2.08p ps=8.52u w=8u l=0.28u
X31 VDD.t13 SENSE_CLK.t40 XP.t2 VDD.t12 pfet_03v3 ad=2.08p pd=8.52u as=3.52p ps=16.88u w=8u l=0.28u
X32 NIN.t26 INN.t0 NTAIL.t46 VSS.t161 nfet_03v3 ad=3.52p pd=16.88u as=2.08p ps=8.52u w=8u l=0.28u
X33 NIP.t6 XN.t41 XP.t21 VSS.t30 nfet_03v3 ad=2.08p pd=8.52u as=2.08p ps=8.52u w=8u l=0.28u
X34 H.t16 DP.t6 VSS.t145 VSS.t144 nfet_03v3 ad=3.52p pd=16.88u as=2.08p ps=8.52u w=8u l=0.28u
X35 VDD.t37 SENSE_CLK.t30 NIP.t0 VDD.t36 pfet_03v3 ad=2.08p pd=8.52u as=3.52p ps=16.88u w=8u l=0.28u
X36 XN.t1 SENSE_CLK.t13 VDD.t7 VDD.t6 pfet_03v3 ad=2.08p pd=8.52u as=2.08p ps=8.52u w=8u l=0.28u
X37 OUTP.t4 H.t27 VDD.t89 VDD.t88 pfet_03v3 ad=2.08p pd=8.52u as=2.08p ps=8.52u w=8u l=0.28u
X38 NTAIL.t20 SENSE_BOOST_CLK.t20 VSS.t94 VSS.t93 nfet_03v3 ad=2.6p pd=10.52u as=2.6p ps=10.52u w=10u l=0.28u
X39 H.t1 XN.t54 VDD.t85 VDD.t84 pfet_03v3 ad=2.08p pd=8.52u as=2.08p ps=8.52u w=8u l=0.28u
X40 HB.t1 XP.t50 VDD.t5 VDD.t4 pfet_03v3 ad=3.52p pd=16.88u as=2.08p ps=8.52u w=8u l=0.28u
X41 XN.t12 SENSE_CLK.t24 XP.t0 VDD.t46 pfet_03v3 ad=2.08p pd=8.52u as=2.08p ps=8.52u w=8u l=0.28u
X42 XN.t9 SENSE_CLK.t5 VDD.t17 VDD.t16 pfet_03v3 ad=3.52p pd=16.88u as=2.08p ps=8.52u w=8u l=0.28u
X43 VSS.t122 SENSE_BOOST_CLK.t7 NTAIL.t33 VSS.t34 nfet_03v3 ad=2.6p pd=10.52u as=2.6p ps=10.52u w=10u l=0.28u
X44 NIP.t1 SENSE_CLK.t29 VDD.t39 VDD.t38 pfet_03v3 ad=2.08p pd=8.52u as=2.08p ps=8.52u w=8u l=0.28u
X45 VSS.t71 DP.t13 H.t9 VSS.t70 nfet_03v3 ad=2.08p pd=8.52u as=3.52p ps=16.88u w=8u l=0.28u
X46 NTAIL.t47 INN.t7 NIN.t19 VSS.t154 nfet_03v3 ad=2.08p pd=8.52u as=2.08p ps=8.52u w=8u l=0.28u
X47 XP.t16 SENSE_CLK.t23 XN.t13 VDD.t47 pfet_03v3 ad=2.08p pd=8.52u as=2.08p ps=8.52u w=8u l=0.28u
X48 NIN.t9 XP.t35 XN.t28 VSS.t39 nfet_03v3 ad=2.08p pd=8.52u as=2.08p ps=8.52u w=8u l=0.28u
X49 XP.t30 XN.t34 NIP.t26 VSS.t81 nfet_03v3 ad=2.08p pd=8.52u as=2.08p ps=8.52u w=8u l=0.28u
X50 NIN.t22 INN.t4 NTAIL.t52 VSS.t157 nfet_03v3 ad=2.08p pd=8.52u as=2.08p ps=8.52u w=8u l=0.28u
X51 VDD.t15 SENSE_CLK.t6 XN.t8 VDD.t14 pfet_03v3 ad=2.08p pd=8.52u as=2.08p ps=8.52u w=8u l=0.28u
X52 NTAIL.t1 SENSE_CLK.t3 VSS.t3 VSS.t2 nfet_03v3 ad=2.6p pd=10.52u as=2.6p ps=10.52u w=10u l=0.28u
X53 XN.t31 XP.t32 NIN.t27 VSS.t162 nfet_03v3 ad=3.52p pd=16.88u as=2.08p ps=8.52u w=8u l=0.28u
X54 NIP.t7 XN.t37 XP.t22 VSS.t31 nfet_03v3 ad=2.08p pd=8.52u as=2.08p ps=8.52u w=8u l=0.28u
X55 VDD.t57 SENSE_CLK.t16 NIN.t2 VDD.t56 pfet_03v3 ad=2.08p pd=8.52u as=2.08p ps=8.52u w=8u l=0.28u
X56 H.t10 DP.t12 VSS.t33 VSS.t32 nfet_03v3 ad=2.08p pd=8.52u as=2.08p ps=8.52u w=8u l=0.28u
X57 XN.t21 XP.t42 NIN.t4 VSS.t12 nfet_03v3 ad=2.08p pd=8.52u as=2.08p ps=8.52u w=8u l=0.28u
X58 DP.t4 XP.t46 VDD.t127 VDD.t126 pfet_03v3 ad=3.52p pd=16.88u as=2.08p ps=8.52u w=8u l=0.28u
X59 NIN.t6 XP.t39 XN.t24 VSS.t28 nfet_03v3 ad=2.08p pd=8.52u as=2.08p ps=8.52u w=8u l=0.28u
X60 DP.t3 XP.t44 VSS.t141 VSS.t140 nfet_03v3 ad=3.52p pd=16.88u as=2.08p ps=8.52u w=8u l=0.28u
X61 VDD.t129 XP.t55 XN.t18 VDD.t128 pfet_03v3 ad=2.08p pd=8.52u as=3.52p ps=16.88u w=8u l=0.28u
X62 VSS.t108 SENSE_BOOST_CLK.t15 NTAIL.t25 VSS.t107 nfet_03v3 ad=2.6p pd=10.52u as=2.6p ps=10.52u w=10u l=0.28u
X63 VSS.t35 XN.t45 DN.t3 VSS.t34 nfet_03v3 ad=2.08p pd=8.52u as=3.52p ps=16.88u w=8u l=0.28u
X64 NTAIL.t38 SENSE_BOOST_CLK.t2 VSS.t126 VSS.t125 nfet_03v3 ad=2.6p pd=10.52u as=2.6p ps=10.52u w=10u l=0.28u
X65 VDD.t33 SENSE_CLK.t32 XP.t10 VDD.t32 pfet_03v3 ad=2.08p pd=8.52u as=2.08p ps=8.52u w=8u l=0.28u
X66 NIN.t20 INN.t6 NTAIL.t50 VSS.t155 nfet_03v3 ad=2.08p pd=8.52u as=2.08p ps=8.52u w=8u l=0.28u
X67 VDD.t75 XN.t53 H.t0 VDD.t74 pfet_03v3 ad=2.08p pd=8.52u as=2.08p ps=8.52u w=8u l=0.28u
X68 VSS.t100 SENSE_BOOST_CLK.t21 NTAIL.t19 VSS.t99 nfet_03v3 ad=2.6p pd=10.52u as=2.6p ps=10.52u w=10u l=0.28u
X69 VDD.t123 XP.t51 HB.t15 VDD.t122 pfet_03v3 ad=2.08p pd=8.52u as=2.08p ps=8.52u w=8u l=0.28u
X70 NTAIL.t49 INN.t3 NIN.t23 VSS.t158 nfet_03v3 ad=2.08p pd=8.52u as=2.08p ps=8.52u w=8u l=0.28u
X71 XP.t19 XN.t38 NIP.t5 VSS.t17 nfet_03v3 ad=2.08p pd=8.52u as=2.08p ps=8.52u w=8u l=0.28u
X72 XP.t11 SENSE_CLK.t31 VDD.t35 VDD.t34 pfet_03v3 ad=3.52p pd=16.88u as=2.08p ps=8.52u w=8u l=0.28u
X73 OUTP.t5 H.t18 VSS.t77 VSS.t76 nfet_03v3 ad=3.52p pd=16.88u as=2.08p ps=8.52u w=8u l=0.28u
X74 NTAIL.t22 SENSE_BOOST_CLK.t18 VSS.t102 VSS.t101 nfet_03v3 ad=2.6p pd=10.52u as=2.6p ps=10.52u w=10u l=0.28u
X75 OUTN.t4 HB.t17 VSS.t139 VSS.t138 nfet_03v3 ad=3.52p pd=16.88u as=2.08p ps=8.52u w=8u l=0.28u
X76 VSS.t85 DN.t9 HB.t10 VSS.t84 nfet_03v3 ad=2.08p pd=8.52u as=2.08p ps=8.52u w=8u l=0.28u
X77 XP.t3 SENSE_CLK.t39 VDD.t11 VDD.t10 pfet_03v3 ad=2.08p pd=8.52u as=2.08p ps=8.52u w=8u l=0.28u
X78 XN.t25 XP.t38 NIN.t12 VSS.t72 nfet_03v3 ad=2.08p pd=8.52u as=2.08p ps=8.52u w=8u l=0.28u
X79 VSS.t1 HB.t21 H.t6 VSS.t0 nfet_03v3 ad=3.52p pd=16.88u as=3.52p ps=16.88u w=8u l=0.28u
X80 VDD.t59 SENSE_CLK.t14 XN.t0 VDD.t58 pfet_03v3 ad=2.08p pd=8.52u as=3.52p ps=16.88u w=8u l=0.28u
X81 VDD.t81 H.t26 OUTP.t3 VDD.t80 pfet_03v3 ad=3.52p pd=16.88u as=2.08p ps=8.52u w=8u l=0.28u
X82 VDD.t19 SENSE_CLK.t38 XP.t4 VDD.t18 pfet_03v3 ad=2.08p pd=8.52u as=2.08p ps=8.52u w=8u l=0.28u
X83 VSS.t149 H.t17 HB.t16 VSS.t148 nfet_03v3 ad=3.52p pd=16.88u as=3.52p ps=16.88u w=8u l=0.28u
X84 VDD.t41 SENSE_CLK.t28 NIP.t2 VDD.t40 pfet_03v3 ad=2.08p pd=8.52u as=2.08p ps=8.52u w=8u l=0.28u
X85 NTAIL.t30 SENSE_BOOST_CLK.t10 VSS.t116 VSS.t115 nfet_03v3 ad=2.6p pd=10.52u as=2.6p ps=10.52u w=10u l=0.28u
X86 NIP.t13 INP.t10 NTAIL.t7 VSS.t53 nfet_03v3 ad=2.08p pd=8.52u as=2.08p ps=8.52u w=8u l=0.28u
X87 XN.t7 SENSE_CLK.t7 VDD.t69 VDD.t68 pfet_03v3 ad=2.08p pd=8.52u as=2.08p ps=8.52u w=8u l=0.28u
X88 H.t3 HB.t27 VDD.t115 VDD.t114 pfet_03v3 ad=2.08p pd=8.52u as=2.08p ps=8.52u w=8u l=0.28u
X89 NIN.t1 SENSE_CLK.t17 VDD.t55 VDD.t54 pfet_03v3 ad=2.08p pd=8.52u as=2.08p ps=8.52u w=8u l=0.28u
X90 VSS.t47 DP.t11 H.t11 VSS.t46 nfet_03v3 ad=2.08p pd=8.52u as=2.08p ps=8.52u w=8u l=0.28u
X91 VSS.t11 SENSE_CLK.t0 NTAIL.t4 VSS.t10 nfet_03v3 ad=4.4p pd=20.88u as=2.6p ps=10.52u w=10u l=0.28u
X92 VSS.t137 DP.t9 H.t13 VSS.t136 nfet_03v3 ad=2.08p pd=8.52u as=2.08p ps=8.52u w=8u l=0.28u
X93 NTAIL.t24 SENSE_BOOST_CLK.t16 VSS.t106 VSS.t105 nfet_03v3 ad=2.6p pd=10.52u as=2.6p ps=10.52u w=10u l=0.28u
X94 VDD.t65 SENSE_CLK.t8 XN.t6 VDD.t64 pfet_03v3 ad=2.08p pd=8.52u as=2.08p ps=8.52u w=8u l=0.28u
X95 VDD.t91 H.t23 HB.t4 VDD.t90 pfet_03v3 ad=2.08p pd=8.52u as=2.08p ps=8.52u w=8u l=0.28u
X96 VDD.t53 SENSE_CLK.t18 NIN.t0 VDD.t52 pfet_03v3 ad=2.08p pd=8.52u as=3.52p ps=16.88u w=8u l=0.28u
X97 NIN.t24 INN.t2 NTAIL.t43 VSS.t159 nfet_03v3 ad=2.08p pd=8.52u as=2.08p ps=8.52u w=8u l=0.28u
X98 NTAIL.t11 INP.t3 NIP.t20 VSS.t60 nfet_03v3 ad=2.08p pd=8.52u as=2.08p ps=8.52u w=8u l=0.28u
X99 NIP.t9 XN.t39 XP.t24 VSS.t37 nfet_03v3 ad=2.08p pd=8.52u as=2.08p ps=8.52u w=8u l=0.28u
X100 H.t12 DP.t10 VSS.t45 VSS.t44 nfet_03v3 ad=2.08p pd=8.52u as=2.08p ps=8.52u w=8u l=0.28u
X101 VSS.t110 SENSE_BOOST_CLK.t13 NTAIL.t27 VSS.t109 nfet_03v3 ad=2.6p pd=10.52u as=2.6p ps=10.52u w=10u l=0.28u
X102 NIP.t17 INP.t6 NTAIL.t6 VSS.t57 nfet_03v3 ad=2.08p pd=8.52u as=2.08p ps=8.52u w=8u l=0.28u
X103 XP.t18 XN.t42 NIP.t4 VSS.t16 nfet_03v3 ad=2.08p pd=8.52u as=2.08p ps=8.52u w=8u l=0.28u
X104 HB.t9 DN.t10 VSS.t19 VSS.t18 nfet_03v3 ad=2.08p pd=8.52u as=2.08p ps=8.52u w=8u l=0.28u
X105 H.t8 XN.t52 VDD.t109 VDD.t108 pfet_03v3 ad=3.52p pd=16.88u as=2.08p ps=8.52u w=8u l=0.28u
X106 NTAIL.t18 SENSE_BOOST_CLK.t22 VSS.t98 VSS.t97 nfet_03v3 ad=2.6p pd=10.52u as=2.6p ps=10.52u w=10u l=0.28u
X107 HB.t14 XP.t52 VDD.t119 VDD.t118 pfet_03v3 ad=2.08p pd=8.52u as=2.08p ps=8.52u w=8u l=0.28u
X108 HB.t3 H.t22 VDD.t83 VDD.t82 pfet_03v3 ad=3.52p pd=16.88u as=2.08p ps=8.52u w=8u l=0.28u
X109 NIN.t5 XP.t37 XN.t26 VSS.t13 nfet_03v3 ad=2.08p pd=8.52u as=2.08p ps=8.52u w=8u l=0.28u
X110 NTAIL.t45 INN.t9 NIN.t17 VSS.t152 nfet_03v3 ad=2.08p pd=8.52u as=2.08p ps=8.52u w=8u l=0.28u
X111 NIP.t23 INP.t0 NTAIL.t12 VSS.t4 nfet_03v3 ad=3.52p pd=16.88u as=2.08p ps=8.52u w=8u l=0.28u
X112 XP.t31 XN.t32 NIP.t27 VSS.t135 nfet_03v3 ad=3.52p pd=16.88u as=2.08p ps=8.52u w=8u l=0.28u
X113 VSS.t67 DN.t11 HB.t8 VSS.t66 nfet_03v3 ad=2.08p pd=8.52u as=2.08p ps=8.52u w=8u l=0.28u
X114 VDD.t107 XN.t55 H.t7 VDD.t106 pfet_03v3 ad=2.08p pd=8.52u as=3.52p ps=16.88u w=8u l=0.28u
X115 VSS.t92 SENSE_BOOST_CLK.t19 NTAIL.t21 VSS.t91 nfet_03v3 ad=2.6p pd=10.52u as=2.6p ps=10.52u w=10u l=0.28u
X116 XN.t29 XP.t34 NIN.t7 VSS.t29 nfet_03v3 ad=2.08p pd=8.52u as=2.08p ps=8.52u w=8u l=0.28u
X117 NIP.t25 XN.t35 XP.t29 VSS.t73 nfet_03v3 ad=2.08p pd=8.52u as=2.08p ps=8.52u w=8u l=0.28u
X118 VSS.t124 SENSE_BOOST_CLK.t5 NTAIL.t35 VSS.t123 nfet_03v3 ad=2.6p pd=10.52u as=2.6p ps=10.52u w=10u l=0.28u
X119 NTAIL.t48 INN.t11 NIN.t15 VSS.t150 nfet_03v3 ad=2.08p pd=8.52u as=3.52p ps=16.88u w=8u l=0.28u
X120 NIN.t10 XP.t41 XN.t22 VSS.t42 nfet_03v3 ad=2.08p pd=8.52u as=2.08p ps=8.52u w=8u l=0.28u
X121 DP.t5 XP.t48 VDD.t131 VDD.t130 pfet_03v3 ad=2.08p pd=8.52u as=2.08p ps=8.52u w=8u l=0.28u
X122 VSS.t114 SENSE_BOOST_CLK.t11 NTAIL.t29 VSS.t113 nfet_03v3 ad=2.6p pd=10.52u as=2.6p ps=10.52u w=10u l=0.28u
X123 VSS.t147 HB.t18 OUTN.t6 VSS.t146 nfet_03v3 ad=2.08p pd=8.52u as=2.08p ps=8.52u w=8u l=0.28u
X124 XP.t17 SENSE_CLK.t19 XN.t17 VDD.t51 pfet_03v3 ad=3.52p pd=16.88u as=2.08p ps=8.52u w=8u l=0.28u
X125 NTAIL.t41 INN.t1 NIN.t25 VSS.t160 nfet_03v3 ad=2.08p pd=8.52u as=2.08p ps=8.52u w=8u l=0.28u
X126 NIP.t19 INP.t4 NTAIL.t13 VSS.t59 nfet_03v3 ad=2.08p pd=8.52u as=2.08p ps=8.52u w=8u l=0.28u
X127 VDD.t71 XN.t47 DN.t0 VDD.t70 pfet_03v3 ad=2.08p pd=8.52u as=2.08p ps=8.52u w=8u l=0.28u
X128 NTAIL.t32 SENSE_BOOST_CLK.t8 VSS.t121 VSS.t120 nfet_03v3 ad=2.6p pd=10.52u as=2.6p ps=10.52u w=10u l=0.28u
X129 NTAIL.t9 INP.t7 NIP.t16 VSS.t56 nfet_03v3 ad=2.08p pd=8.52u as=2.08p ps=8.52u w=8u l=0.28u
X130 VDD.t121 HB.t22 OUTN.t5 VDD.t120 pfet_03v3 ad=3.52p pd=16.88u as=2.08p ps=8.52u w=8u l=0.28u
X131 VSS.t104 SENSE_BOOST_CLK.t17 NTAIL.t23 VSS.t103 nfet_03v3 ad=2.6p pd=10.52u as=2.6p ps=10.52u w=10u l=0.28u
X132 XP.t5 SENSE_CLK.t37 VDD.t23 VDD.t22 pfet_03v3 ad=2.08p pd=8.52u as=2.08p ps=8.52u w=8u l=0.28u
X133 VSS.t7 SENSE_CLK.t2 NTAIL.t2 VSS.t6 nfet_03v3 ad=2.6p pd=10.52u as=2.6p ps=10.52u w=10u l=0.28u
X134 NIP.t3 SENSE_CLK.t27 VDD.t43 VDD.t42 pfet_03v3 ad=3.52p pd=16.88u as=2.08p ps=8.52u w=8u l=0.28u
X135 DN.t5 XN.t46 VDD.t105 VDD.t104 pfet_03v3 ad=3.52p pd=16.88u as=2.08p ps=8.52u w=8u l=0.28u
X136 NIN.t18 INN.t8 NTAIL.t42 VSS.t153 nfet_03v3 ad=2.08p pd=8.52u as=2.08p ps=8.52u w=8u l=0.28u
X137 VDD.t87 XN.t51 XP.t25 VDD.t86 pfet_03v3 ad=2.08p pd=8.52u as=3.52p ps=16.88u w=8u l=0.28u
X138 NTAIL.t26 SENSE_BOOST_CLK.t14 VSS.t90 VSS.t89 nfet_03v3 ad=2.6p pd=10.52u as=2.6p ps=10.52u w=10u l=0.28u
X139 VSS.t27 H.t21 OUTP.t2 VSS.t26 nfet_03v3 ad=2.08p pd=8.52u as=3.52p ps=16.88u w=8u l=0.28u
X140 NTAIL.t44 INN.t5 NIN.t21 VSS.t156 nfet_03v3 ad=2.08p pd=8.52u as=2.08p ps=8.52u w=8u l=0.28u
X141 XP.t27 XN.t36 NIP.t11 VSS.t49 nfet_03v3 ad=2.08p pd=8.52u as=2.08p ps=8.52u w=8u l=0.28u
X142 VDD.t125 HB.t26 H.t4 VDD.t124 pfet_03v3 ad=2.08p pd=8.52u as=2.08p ps=8.52u w=8u l=0.28u
X143 NIN.t13 XP.t33 XN.t30 VSS.t80 nfet_03v3 ad=2.08p pd=8.52u as=2.08p ps=8.52u w=8u l=0.28u
X144 VDD.t25 SENSE_CLK.t36 XP.t6 VDD.t24 pfet_03v3 ad=2.08p pd=8.52u as=2.08p ps=8.52u w=8u l=0.28u
X145 VDD.t101 HB.t28 H.t2 VDD.t100 pfet_03v3 ad=2.08p pd=8.52u as=3.52p ps=16.88u w=8u l=0.28u
X146 HB.t13 DN.t6 VSS.t83 VSS.t82 nfet_03v3 ad=3.52p pd=16.88u as=2.08p ps=8.52u w=8u l=0.28u
X147 H.t14 DP.t8 VSS.t88 VSS.t87 nfet_03v3 ad=2.08p pd=8.52u as=2.08p ps=8.52u w=8u l=0.28u
X148 XN.t3 SENSE_CLK.t11 VDD.t9 VDD.t8 pfet_03v3 ad=2.08p pd=8.52u as=2.08p ps=8.52u w=8u l=0.28u
X149 OUTP.t1 H.t20 VSS.t25 VSS.t24 nfet_03v3 ad=2.08p pd=8.52u as=2.08p ps=8.52u w=8u l=0.28u
X150 XN.t5 SENSE_CLK.t9 VDD.t67 VDD.t66 pfet_03v3 ad=2.08p pd=8.52u as=2.08p ps=8.52u w=8u l=0.28u
X151 HB.t0 H.t24 VDD.t3 VDD.t2 pfet_03v3 ad=2.08p pd=8.52u as=2.08p ps=8.52u w=8u l=0.28u
X152 NIN.t14 XP.t43 XN.t20 VSS.t86 nfet_03v3 ad=2.08p pd=8.52u as=3.52p ps=16.88u w=8u l=0.28u
X153 XN.t10 SENSE_CLK.t26 XP.t15 VDD.t44 pfet_03v3 ad=2.08p pd=8.52u as=3.52p ps=16.88u w=8u l=0.28u
X154 XN.t23 XP.t40 NIN.t8 VSS.t38 nfet_03v3 ad=2.08p pd=8.52u as=2.08p ps=8.52u w=8u l=0.28u
X155 VSS.t64 DP.t7 H.t15 VSS.t63 nfet_03v3 ad=2.08p pd=8.52u as=2.08p ps=8.52u w=8u l=0.28u
X156 VDD.t73 H.t25 HB.t2 VDD.t72 pfet_03v3 ad=2.08p pd=8.52u as=3.52p ps=16.88u w=8u l=0.28u
X157 XP.t13 SENSE_CLK.t25 XN.t11 VDD.t45 pfet_03v3 ad=2.08p pd=8.52u as=2.08p ps=8.52u w=8u l=0.28u
X158 VSS.t130 SENSE_BOOST_CLK.t3 NTAIL.t37 VSS.t129 nfet_03v3 ad=2.6p pd=10.52u as=2.6p ps=10.52u w=10u l=0.28u
X159 HB.t7 DN.t12 VSS.t143 VSS.t142 nfet_03v3 ad=2.08p pd=8.52u as=2.08p ps=8.52u w=8u l=0.28u
X160 NIP.t15 INP.t8 NTAIL.t16 VSS.t55 nfet_03v3 ad=2.08p pd=8.52u as=2.08p ps=8.52u w=8u l=0.28u
X161 NTAIL.t40 SENSE_BOOST_CLK.t0 VSS.t134 VSS.t133 nfet_03v3 ad=4.4p pd=20.88u as=2.6p ps=10.52u w=10u l=0.28u
X162 NTAIL.t10 INP.t11 NIP.t12 VSS.t52 nfet_03v3 ad=2.08p pd=8.52u as=3.52p ps=16.88u w=8u l=0.28u
X163 NIN.t3 SENSE_CLK.t15 VDD.t21 VDD.t20 pfet_03v3 ad=3.52p pd=16.88u as=2.08p ps=8.52u w=8u l=0.28u
X164 VSS.t118 SENSE_BOOST_CLK.t9 NTAIL.t31 VSS.t117 nfet_03v3 ad=2.6p pd=10.52u as=2.6p ps=10.52u w=10u l=0.28u
X165 VSS.t21 DN.t13 HB.t6 VSS.t20 nfet_03v3 ad=2.08p pd=8.52u as=3.52p ps=16.88u w=8u l=0.28u
X166 NTAIL.t34 SENSE_BOOST_CLK.t6 VSS.t119 VSS.t14 nfet_03v3 ad=2.6p pd=10.52u as=2.6p ps=10.52u w=10u l=0.28u
X167 VDD.t97 XP.t47 DP.t1 VDD.t96 pfet_03v3 ad=2.08p pd=8.52u as=2.08p ps=8.52u w=8u l=0.28u
X168 NTAIL.t3 SENSE_CLK.t1 VSS.t9 VSS.t8 nfet_03v3 ad=2.6p pd=10.52u as=2.6p ps=10.52u w=10u l=0.28u
X169 XP.t26 XN.t40 NIP.t10 VSS.t48 nfet_03v3 ad=2.08p pd=8.52u as=2.08p ps=8.52u w=8u l=0.28u
X170 OUTN.t1 HB.t19 VSS.t69 VSS.t68 nfet_03v3 ad=2.08p pd=8.52u as=2.08p ps=8.52u w=8u l=0.28u
X171 XN.t14 SENSE_CLK.t22 XP.t14 VDD.t48 pfet_03v3 ad=2.08p pd=8.52u as=2.08p ps=8.52u w=8u l=0.28u
X172 VDD.t93 XP.t49 DP.t0 VDD.t92 pfet_03v3 ad=2.08p pd=8.52u as=3.52p ps=16.88u w=8u l=0.28u
X173 XN.t19 XP.t54 VDD.t95 VDD.t94 pfet_03v3 ad=3.52p pd=16.88u as=2.08p ps=8.52u w=8u l=0.28u
X174 XN.t16 SENSE_CLK.t20 XP.t12 VDD.t50 pfet_03v3 ad=2.08p pd=8.52u as=2.08p ps=8.52u w=8u l=0.28u
X175 NIP.t8 XN.t43 XP.t23 VSS.t36 nfet_03v3 ad=2.08p pd=8.52u as=3.52p ps=16.88u w=8u l=0.28u
X176 VSS.t51 XP.t45 DP.t2 VSS.t50 nfet_03v3 ad=2.08p pd=8.52u as=3.52p ps=16.88u w=8u l=0.28u
R0 SENSE_BOOST_CLK.t23 SENSE_BOOST_CLK.n52 153.859
R1 SENSE_BOOST_CLK.t0 SENSE_BOOST_CLK.n23 153.859
R2 SENSE_BOOST_CLK.t13 SENSE_BOOST_CLK.n38 153.739
R3 SENSE_BOOST_CLK.t15 SENSE_BOOST_CLK.n62 153.739
R4 SENSE_BOOST_CLK.n61 SENSE_BOOST_CLK.t16 153.739
R5 SENSE_BOOST_CLK.n52 SENSE_BOOST_CLK.t22 153.739
R6 SENSE_BOOST_CLK.n51 SENSE_BOOST_CLK.t21 153.739
R7 SENSE_BOOST_CLK.n50 SENSE_BOOST_CLK.t20 153.739
R8 SENSE_BOOST_CLK.n49 SENSE_BOOST_CLK.t19 153.739
R9 SENSE_BOOST_CLK.t18 SENSE_BOOST_CLK.n43 153.739
R10 SENSE_BOOST_CLK.n60 SENSE_BOOST_CLK.t17 153.739
R11 SENSE_BOOST_CLK.t14 SENSE_BOOST_CLK.n0 153.739
R12 SENSE_BOOST_CLK.n23 SENSE_BOOST_CLK.t1 153.739
R13 SENSE_BOOST_CLK.n22 SENSE_BOOST_CLK.t2 153.739
R14 SENSE_BOOST_CLK.n21 SENSE_BOOST_CLK.t3 153.739
R15 SENSE_BOOST_CLK.n20 SENSE_BOOST_CLK.t4 153.739
R16 SENSE_BOOST_CLK.n19 SENSE_BOOST_CLK.t5 153.739
R17 SENSE_BOOST_CLK.n18 SENSE_BOOST_CLK.t6 153.739
R18 SENSE_BOOST_CLK.n17 SENSE_BOOST_CLK.t7 153.739
R19 SENSE_BOOST_CLK.n16 SENSE_BOOST_CLK.t8 153.739
R20 SENSE_BOOST_CLK.n15 SENSE_BOOST_CLK.t9 153.739
R21 SENSE_BOOST_CLK.t10 SENSE_BOOST_CLK.n3 153.739
R22 SENSE_BOOST_CLK.n36 SENSE_BOOST_CLK.t11 153.739
R23 SENSE_BOOST_CLK.n37 SENSE_BOOST_CLK.t12 153.739
R24 SENSE_BOOST_CLK.n53 SENSE_BOOST_CLK.t23 139.702
R25 SENSE_BOOST_CLK.n24 SENSE_BOOST_CLK.t0 139.702
R26 SENSE_BOOST_CLK.n39 SENSE_BOOST_CLK.t13 135.246
R27 SENSE_BOOST_CLK.n63 SENSE_BOOST_CLK.t15 135.246
R28 SENSE_BOOST_CLK.t16 SENSE_BOOST_CLK.n42 135.246
R29 SENSE_BOOST_CLK.n54 SENSE_BOOST_CLK.t22 135.246
R30 SENSE_BOOST_CLK.n55 SENSE_BOOST_CLK.t21 135.246
R31 SENSE_BOOST_CLK.n56 SENSE_BOOST_CLK.t20 135.246
R32 SENSE_BOOST_CLK.n57 SENSE_BOOST_CLK.t19 135.246
R33 SENSE_BOOST_CLK.n58 SENSE_BOOST_CLK.t18 135.246
R34 SENSE_BOOST_CLK.t17 SENSE_BOOST_CLK.n59 135.246
R35 SENSE_BOOST_CLK.n40 SENSE_BOOST_CLK.t14 135.246
R36 SENSE_BOOST_CLK.n25 SENSE_BOOST_CLK.t1 135.246
R37 SENSE_BOOST_CLK.n26 SENSE_BOOST_CLK.t2 135.246
R38 SENSE_BOOST_CLK.n27 SENSE_BOOST_CLK.t3 135.246
R39 SENSE_BOOST_CLK.n28 SENSE_BOOST_CLK.t4 135.246
R40 SENSE_BOOST_CLK.n29 SENSE_BOOST_CLK.t5 135.246
R41 SENSE_BOOST_CLK.n30 SENSE_BOOST_CLK.t6 135.246
R42 SENSE_BOOST_CLK.n31 SENSE_BOOST_CLK.t7 135.246
R43 SENSE_BOOST_CLK.n32 SENSE_BOOST_CLK.t8 135.246
R44 SENSE_BOOST_CLK.n33 SENSE_BOOST_CLK.t9 135.246
R45 SENSE_BOOST_CLK.n34 SENSE_BOOST_CLK.t10 135.246
R46 SENSE_BOOST_CLK.t11 SENSE_BOOST_CLK.n35 135.246
R47 SENSE_BOOST_CLK.t12 SENSE_BOOST_CLK.n2 135.246
R48 SENSE_BOOST_CLK SENSE_BOOST_CLK.n66 31.5205
R49 SENSE_BOOST_CLK.n39 SENSE_BOOST_CLK.n1 18.4942
R50 SENSE_BOOST_CLK.n64 SENSE_BOOST_CLK.n63 18.4942
R51 SENSE_BOOST_CLK.n42 SENSE_BOOST_CLK.n41 18.4942
R52 SENSE_BOOST_CLK.n55 SENSE_BOOST_CLK.n48 18.4942
R53 SENSE_BOOST_CLK.n56 SENSE_BOOST_CLK.n47 18.4942
R54 SENSE_BOOST_CLK.n57 SENSE_BOOST_CLK.n46 18.4942
R55 SENSE_BOOST_CLK.n58 SENSE_BOOST_CLK.n45 18.4942
R56 SENSE_BOOST_CLK.n59 SENSE_BOOST_CLK.n44 18.4942
R57 SENSE_BOOST_CLK.n65 SENSE_BOOST_CLK.n40 18.4942
R58 SENSE_BOOST_CLK.n26 SENSE_BOOST_CLK.n14 18.4942
R59 SENSE_BOOST_CLK.n27 SENSE_BOOST_CLK.n13 18.4942
R60 SENSE_BOOST_CLK.n28 SENSE_BOOST_CLK.n12 18.4942
R61 SENSE_BOOST_CLK.n29 SENSE_BOOST_CLK.n11 18.4942
R62 SENSE_BOOST_CLK.n30 SENSE_BOOST_CLK.n10 18.4942
R63 SENSE_BOOST_CLK.n31 SENSE_BOOST_CLK.n9 18.4942
R64 SENSE_BOOST_CLK.n32 SENSE_BOOST_CLK.n8 18.4942
R65 SENSE_BOOST_CLK.n33 SENSE_BOOST_CLK.n7 18.4942
R66 SENSE_BOOST_CLK.n34 SENSE_BOOST_CLK.n6 18.4942
R67 SENSE_BOOST_CLK.n35 SENSE_BOOST_CLK.n5 18.4942
R68 SENSE_BOOST_CLK.n4 SENSE_BOOST_CLK.n2 18.4942
R69 SENSE_BOOST_CLK.n63 SENSE_BOOST_CLK.n40 11.6805
R70 SENSE_BOOST_CLK.n63 SENSE_BOOST_CLK.n42 11.6805
R71 SENSE_BOOST_CLK.n55 SENSE_BOOST_CLK.n54 11.6805
R72 SENSE_BOOST_CLK.n56 SENSE_BOOST_CLK.n55 11.6805
R73 SENSE_BOOST_CLK.n57 SENSE_BOOST_CLK.n56 11.6805
R74 SENSE_BOOST_CLK.n58 SENSE_BOOST_CLK.n57 11.6805
R75 SENSE_BOOST_CLK.n59 SENSE_BOOST_CLK.n58 11.6805
R76 SENSE_BOOST_CLK.n59 SENSE_BOOST_CLK.n42 11.6805
R77 SENSE_BOOST_CLK.n40 SENSE_BOOST_CLK.n39 11.6805
R78 SENSE_BOOST_CLK.n26 SENSE_BOOST_CLK.n25 11.6805
R79 SENSE_BOOST_CLK.n27 SENSE_BOOST_CLK.n26 11.6805
R80 SENSE_BOOST_CLK.n28 SENSE_BOOST_CLK.n27 11.6805
R81 SENSE_BOOST_CLK.n29 SENSE_BOOST_CLK.n28 11.6805
R82 SENSE_BOOST_CLK.n30 SENSE_BOOST_CLK.n29 11.6805
R83 SENSE_BOOST_CLK.n31 SENSE_BOOST_CLK.n30 11.6805
R84 SENSE_BOOST_CLK.n32 SENSE_BOOST_CLK.n31 11.6805
R85 SENSE_BOOST_CLK.n33 SENSE_BOOST_CLK.n32 11.6805
R86 SENSE_BOOST_CLK.n34 SENSE_BOOST_CLK.n33 11.6805
R87 SENSE_BOOST_CLK.n35 SENSE_BOOST_CLK.n34 11.6805
R88 SENSE_BOOST_CLK.n35 SENSE_BOOST_CLK.n2 11.6805
R89 SENSE_BOOST_CLK.n39 SENSE_BOOST_CLK.n2 11.6805
R90 SENSE_BOOST_CLK.n66 SENSE_BOOST_CLK.n65 10.3505
R91 SENSE_BOOST_CLK.n66 SENSE_BOOST_CLK.n0 9.88093
R92 SENSE_BOOST_CLK.n53 SENSE_BOOST_CLK.n48 7.17687
R93 SENSE_BOOST_CLK.n24 SENSE_BOOST_CLK.n14 7.17687
R94 SENSE_BOOST_CLK.n54 SENSE_BOOST_CLK.n53 4.42851
R95 SENSE_BOOST_CLK.n25 SENSE_BOOST_CLK.n24 4.42851
R96 SENSE_BOOST_CLK.n4 SENSE_BOOST_CLK.n1 0.1205
R97 SENSE_BOOST_CLK.n5 SENSE_BOOST_CLK.n4 0.1205
R98 SENSE_BOOST_CLK.n6 SENSE_BOOST_CLK.n5 0.1205
R99 SENSE_BOOST_CLK.n7 SENSE_BOOST_CLK.n6 0.1205
R100 SENSE_BOOST_CLK.n8 SENSE_BOOST_CLK.n7 0.1205
R101 SENSE_BOOST_CLK.n9 SENSE_BOOST_CLK.n8 0.1205
R102 SENSE_BOOST_CLK.n10 SENSE_BOOST_CLK.n9 0.1205
R103 SENSE_BOOST_CLK.n11 SENSE_BOOST_CLK.n10 0.1205
R104 SENSE_BOOST_CLK.n12 SENSE_BOOST_CLK.n11 0.1205
R105 SENSE_BOOST_CLK.n13 SENSE_BOOST_CLK.n12 0.1205
R106 SENSE_BOOST_CLK.n14 SENSE_BOOST_CLK.n13 0.1205
R107 SENSE_BOOST_CLK.n38 SENSE_BOOST_CLK.n37 0.1205
R108 SENSE_BOOST_CLK.n37 SENSE_BOOST_CLK.n36 0.1205
R109 SENSE_BOOST_CLK.n36 SENSE_BOOST_CLK.n3 0.1205
R110 SENSE_BOOST_CLK.n15 SENSE_BOOST_CLK.n3 0.1205
R111 SENSE_BOOST_CLK.n16 SENSE_BOOST_CLK.n15 0.1205
R112 SENSE_BOOST_CLK.n17 SENSE_BOOST_CLK.n16 0.1205
R113 SENSE_BOOST_CLK.n18 SENSE_BOOST_CLK.n17 0.1205
R114 SENSE_BOOST_CLK.n19 SENSE_BOOST_CLK.n18 0.1205
R115 SENSE_BOOST_CLK.n20 SENSE_BOOST_CLK.n19 0.1205
R116 SENSE_BOOST_CLK.n21 SENSE_BOOST_CLK.n20 0.1205
R117 SENSE_BOOST_CLK.n22 SENSE_BOOST_CLK.n21 0.1205
R118 SENSE_BOOST_CLK.n23 SENSE_BOOST_CLK.n22 0.1205
R119 SENSE_BOOST_CLK.n52 SENSE_BOOST_CLK.n51 0.1205
R120 SENSE_BOOST_CLK.n51 SENSE_BOOST_CLK.n50 0.1205
R121 SENSE_BOOST_CLK.n50 SENSE_BOOST_CLK.n49 0.1205
R122 SENSE_BOOST_CLK.n49 SENSE_BOOST_CLK.n43 0.1205
R123 SENSE_BOOST_CLK.n60 SENSE_BOOST_CLK.n43 0.1205
R124 SENSE_BOOST_CLK.n61 SENSE_BOOST_CLK.n60 0.1205
R125 SENSE_BOOST_CLK.n62 SENSE_BOOST_CLK.n61 0.1205
R126 SENSE_BOOST_CLK.n48 SENSE_BOOST_CLK.n47 0.1205
R127 SENSE_BOOST_CLK.n47 SENSE_BOOST_CLK.n46 0.1205
R128 SENSE_BOOST_CLK.n46 SENSE_BOOST_CLK.n45 0.1205
R129 SENSE_BOOST_CLK.n45 SENSE_BOOST_CLK.n44 0.1205
R130 SENSE_BOOST_CLK.n44 SENSE_BOOST_CLK.n41 0.1205
R131 SENSE_BOOST_CLK.n64 SENSE_BOOST_CLK.n41 0.1205
R132 SENSE_BOOST_CLK.n65 SENSE_BOOST_CLK.n1 0.1085
R133 SENSE_BOOST_CLK.n38 SENSE_BOOST_CLK.n0 0.1085
R134 SENSE_BOOST_CLK.n62 SENSE_BOOST_CLK.n0 0.1085
R135 SENSE_BOOST_CLK.n65 SENSE_BOOST_CLK.n64 0.1085
R136 INN.n25 INN.t11 127.788
R137 INN.t0 INN.n11 127.788
R138 INN.t7 INN.n20 127.668
R139 INN.t9 INN.n26 127.668
R140 INN.n25 INN.t10 127.668
R141 INN.t8 INN.n0 127.668
R142 INN.n11 INN.t1 127.668
R143 INN.n10 INN.t2 127.668
R144 INN.n9 INN.t3 127.668
R145 INN.t4 INN.n3 127.668
R146 INN.n18 INN.t5 127.668
R147 INN.n19 INN.t6 127.668
R148 INN.t11 INN.n23 113.632
R149 INN.n12 INN.t0 113.632
R150 INN.n21 INN.t7 109.174
R151 INN.n27 INN.t9 109.174
R152 INN.t10 INN.n24 109.174
R153 INN.n22 INN.t8 109.174
R154 INN.n13 INN.t1 109.174
R155 INN.n14 INN.t2 109.174
R156 INN.n15 INN.t3 109.174
R157 INN.n16 INN.t4 109.174
R158 INN.t5 INN.n17 109.174
R159 INN.t6 INN.n2 109.174
R160 INN INN.n30 31.3053
R161 INN.n21 INN.n1 18.4942
R162 INN.n28 INN.n27 18.4942
R163 INN.n29 INN.n22 18.4942
R164 INN.n14 INN.n8 18.4942
R165 INN.n15 INN.n7 18.4942
R166 INN.n16 INN.n6 18.4942
R167 INN.n17 INN.n5 18.4942
R168 INN.n4 INN.n2 18.4942
R169 INN.n27 INN.n22 11.6805
R170 INN.n27 INN.n24 11.6805
R171 INN.n22 INN.n21 11.6805
R172 INN.n14 INN.n13 11.6805
R173 INN.n15 INN.n14 11.6805
R174 INN.n16 INN.n15 11.6805
R175 INN.n17 INN.n16 11.6805
R176 INN.n17 INN.n2 11.6805
R177 INN.n21 INN.n2 11.6805
R178 INN.n30 INN.n0 10.8396
R179 INN.n30 INN.n29 9.0005
R180 INN.n28 INN.n23 7.17687
R181 INN.n12 INN.n8 7.17687
R182 INN.n24 INN.n23 4.42851
R183 INN.n13 INN.n12 4.42851
R184 INN.n4 INN.n1 0.1205
R185 INN.n5 INN.n4 0.1205
R186 INN.n6 INN.n5 0.1205
R187 INN.n7 INN.n6 0.1205
R188 INN.n8 INN.n7 0.1205
R189 INN.n20 INN.n19 0.1205
R190 INN.n19 INN.n18 0.1205
R191 INN.n18 INN.n3 0.1205
R192 INN.n9 INN.n3 0.1205
R193 INN.n10 INN.n9 0.1205
R194 INN.n11 INN.n10 0.1205
R195 INN.n26 INN.n25 0.1205
R196 INN.n29 INN.n1 0.1085
R197 INN.n20 INN.n0 0.1085
R198 INN.n26 INN.n0 0.1085
R199 INN.n29 INN.n28 0.1085
R200 INP.t11 INP.n17 127.788
R201 INP.n4 INP.t0 127.788
R202 INP.t2 INP.n5 127.668
R203 INP.t4 INP.n26 127.668
R204 INP.n25 INP.t5 127.668
R205 INP.n17 INP.t10 127.668
R206 INP.n16 INP.t9 127.668
R207 INP.n15 INP.t8 127.668
R208 INP.t7 INP.n10 127.668
R209 INP.n24 INP.t6 127.668
R210 INP.t3 INP.n0 127.668
R211 INP.n4 INP.t1 127.668
R212 INP.n18 INP.t11 113.632
R213 INP.t0 INP.n3 113.632
R214 INP.n6 INP.t2 109.174
R215 INP.n27 INP.t4 109.174
R216 INP.t5 INP.n9 109.174
R217 INP.n19 INP.t10 109.174
R218 INP.n20 INP.t9 109.174
R219 INP.n21 INP.t8 109.174
R220 INP.n22 INP.t7 109.174
R221 INP.t6 INP.n23 109.174
R222 INP.n7 INP.t3 109.174
R223 INP.t1 INP.n2 109.174
R224 INP INP.n30 29.6227
R225 INP.n6 INP.n1 18.4942
R226 INP.n28 INP.n27 18.4942
R227 INP.n9 INP.n8 18.4942
R228 INP.n20 INP.n14 18.4942
R229 INP.n21 INP.n13 18.4942
R230 INP.n22 INP.n12 18.4942
R231 INP.n23 INP.n11 18.4942
R232 INP.n29 INP.n7 18.4942
R233 INP.n27 INP.n7 11.6805
R234 INP.n27 INP.n9 11.6805
R235 INP.n20 INP.n19 11.6805
R236 INP.n21 INP.n20 11.6805
R237 INP.n22 INP.n21 11.6805
R238 INP.n23 INP.n22 11.6805
R239 INP.n23 INP.n9 11.6805
R240 INP.n7 INP.n6 11.6805
R241 INP.n6 INP.n2 11.6805
R242 INP.n30 INP.n0 10.8396
R243 INP.n30 INP.n29 9.0005
R244 INP.n18 INP.n14 7.17687
R245 INP.n3 INP.n1 7.17687
R246 INP.n19 INP.n18 4.42851
R247 INP.n3 INP.n2 4.42851
R248 INP.n5 INP.n4 0.1205
R249 INP.n17 INP.n16 0.1205
R250 INP.n16 INP.n15 0.1205
R251 INP.n15 INP.n10 0.1205
R252 INP.n24 INP.n10 0.1205
R253 INP.n25 INP.n24 0.1205
R254 INP.n26 INP.n25 0.1205
R255 INP.n14 INP.n13 0.1205
R256 INP.n13 INP.n12 0.1205
R257 INP.n12 INP.n11 0.1205
R258 INP.n11 INP.n8 0.1205
R259 INP.n28 INP.n8 0.1205
R260 INP.n29 INP.n1 0.1085
R261 INP.n5 INP.n0 0.1085
R262 INP.n26 INP.n0 0.1085
R263 INP.n29 INP.n28 0.1085
R264 OUTN.n5 OUTN.n2 10.957
R265 OUTN.n5 OUTN.n4 10.5657
R266 OUTN OUTN.n5 8.59007
R267 OUTN.n1 OUTN.t4 5.7796
R268 OUTN.n4 OUTN.t2 5.71396
R269 OUTN.n2 OUTN.t0 5.68486
R270 OUTN.n1 OUTN.n0 5.38537
R271 OUTN.n4 OUTN.n3 5.34435
R272 OUTN.n3 OUTN.t3 0.228
R273 OUTN.n3 OUTN.t5 0.228
R274 OUTN.n0 OUTN.t1 0.20525
R275 OUTN.n0 OUTN.t6 0.20525
R276 OUTN.n2 OUTN.n1 0.0952368
R277 OUTP.n5 OUTP.n1 11.0353
R278 OUTP.n5 OUTP.n4 10.4875
R279 OUTP OUTP.n5 8.47267
R280 OUTP.n3 OUTP.t5 5.7796
R281 OUTP.n1 OUTP.t0 5.71396
R282 OUTP.n4 OUTP.t2 5.68486
R283 OUTP.n3 OUTP.n2 5.38537
R284 OUTP.n1 OUTP.n0 5.34435
R285 OUTP.n0 OUTP.t4 0.228
R286 OUTP.n0 OUTP.t3 0.228
R287 OUTP.n2 OUTP.t1 0.20525
R288 OUTP.n2 OUTP.t6 0.20525
R289 OUTP.n4 OUTP.n3 0.0952368
R290 SENSE_CLK.n58 SENSE_CLK.t0 139.702
R291 SENSE_CLK.n60 SENSE_CLK.t2 135.246
R292 SENSE_CLK.n61 SENSE_CLK.t3 135.246
R293 SENSE_CLK.n62 SENSE_CLK.t4 135.246
R294 SENSE_CLK.n57 SENSE_CLK.t1 135.246
R295 SENSE_CLK.t14 SENSE_CLK.n8 127.788
R296 SENSE_CLK.t26 SENSE_CLK.n45 127.788
R297 SENSE_CLK.t31 SENSE_CLK.n87 127.788
R298 SENSE_CLK.t19 SENSE_CLK.n35 127.776
R299 SENSE_CLK.t5 SENSE_CLK.n0 127.668
R300 SENSE_CLK.t6 SENSE_CLK.n23 127.668
R301 SENSE_CLK.n22 SENSE_CLK.t7 127.668
R302 SENSE_CLK.n21 SENSE_CLK.t8 127.668
R303 SENSE_CLK.t9 SENSE_CLK.n3 127.668
R304 SENSE_CLK.t10 SENSE_CLK.n15 127.668
R305 SENSE_CLK.n14 SENSE_CLK.t11 127.668
R306 SENSE_CLK.n13 SENSE_CLK.t12 127.668
R307 SENSE_CLK.t13 SENSE_CLK.n8 127.668
R308 SENSE_CLK.n45 SENSE_CLK.t25 127.668
R309 SENSE_CLK.n44 SENSE_CLK.t24 127.668
R310 SENSE_CLK.n43 SENSE_CLK.t23 127.668
R311 SENSE_CLK.n42 SENSE_CLK.t22 127.668
R312 SENSE_CLK.n41 SENSE_CLK.t21 127.668
R313 SENSE_CLK.t20 SENSE_CLK.n35 127.668
R314 SENSE_CLK.t40 SENSE_CLK.n72 127.668
R315 SENSE_CLK.n87 SENSE_CLK.t32 127.668
R316 SENSE_CLK.n86 SENSE_CLK.t33 127.668
R317 SENSE_CLK.n85 SENSE_CLK.t34 127.668
R318 SENSE_CLK.n84 SENSE_CLK.t35 127.668
R319 SENSE_CLK.n83 SENSE_CLK.t36 127.668
R320 SENSE_CLK.n82 SENSE_CLK.t37 127.668
R321 SENSE_CLK.n81 SENSE_CLK.t38 127.668
R322 SENSE_CLK.n80 SENSE_CLK.t39 127.668
R323 SENSE_CLK.n29 SENSE_CLK.t18 113.632
R324 SENSE_CLK.n10 SENSE_CLK.t14 113.632
R325 SENSE_CLK.n66 SENSE_CLK.t30 113.632
R326 SENSE_CLK.n46 SENSE_CLK.t26 113.632
R327 SENSE_CLK.n88 SENSE_CLK.t31 113.632
R328 SENSE_CLK.n36 SENSE_CLK.t19 113.629
R329 SENSE_CLK.n30 SENSE_CLK.t17 109.174
R330 SENSE_CLK.n31 SENSE_CLK.t16 109.174
R331 SENSE_CLK.n28 SENSE_CLK.t15 109.174
R332 SENSE_CLK.n25 SENSE_CLK.t5 109.174
R333 SENSE_CLK.n24 SENSE_CLK.t6 109.174
R334 SENSE_CLK.t7 SENSE_CLK.n2 109.174
R335 SENSE_CLK.t8 SENSE_CLK.n20 109.174
R336 SENSE_CLK.n4 SENSE_CLK.t9 109.174
R337 SENSE_CLK.n16 SENSE_CLK.t10 109.174
R338 SENSE_CLK.t11 SENSE_CLK.n7 109.174
R339 SENSE_CLK.t12 SENSE_CLK.n12 109.174
R340 SENSE_CLK.n9 SENSE_CLK.t13 109.174
R341 SENSE_CLK.n67 SENSE_CLK.t29 109.174
R342 SENSE_CLK.n68 SENSE_CLK.t28 109.174
R343 SENSE_CLK.n65 SENSE_CLK.t27 109.174
R344 SENSE_CLK.t25 SENSE_CLK.n40 109.174
R345 SENSE_CLK.n48 SENSE_CLK.t24 109.174
R346 SENSE_CLK.n49 SENSE_CLK.t23 109.174
R347 SENSE_CLK.n50 SENSE_CLK.t22 109.174
R348 SENSE_CLK.n51 SENSE_CLK.t21 109.174
R349 SENSE_CLK.n38 SENSE_CLK.t20 109.174
R350 SENSE_CLK.n97 SENSE_CLK.t40 109.174
R351 SENSE_CLK.n89 SENSE_CLK.t32 109.174
R352 SENSE_CLK.n90 SENSE_CLK.t33 109.174
R353 SENSE_CLK.n91 SENSE_CLK.t34 109.174
R354 SENSE_CLK.n92 SENSE_CLK.t35 109.174
R355 SENSE_CLK.n93 SENSE_CLK.t36 109.174
R356 SENSE_CLK.n94 SENSE_CLK.t37 109.174
R357 SENSE_CLK.n95 SENSE_CLK.t38 109.174
R358 SENSE_CLK.n96 SENSE_CLK.t39 109.174
R359 SENSE_CLK.n34 SENSE_CLK.n33 24.5548
R360 SENSE_CLK.n71 SENSE_CLK.n70 24.5548
R361 SENSE_CLK.n34 SENSE_CLK.n27 20.0548
R362 SENSE_CLK.n63 SENSE_CLK.n62 18.5723
R363 SENSE_CLK.n33 SENSE_CLK.n28 18.5179
R364 SENSE_CLK.n70 SENSE_CLK.n65 18.5179
R365 SENSE_CLK.n32 SENSE_CLK.n31 18.4942
R366 SENSE_CLK.n60 SENSE_CLK.n59 18.4942
R367 SENSE_CLK.n61 SENSE_CLK.n56 18.4942
R368 SENSE_CLK.n26 SENSE_CLK.n25 18.4942
R369 SENSE_CLK.n24 SENSE_CLK.n1 18.4942
R370 SENSE_CLK.n5 SENSE_CLK.n2 18.4942
R371 SENSE_CLK.n20 SENSE_CLK.n19 18.4942
R372 SENSE_CLK.n18 SENSE_CLK.n4 18.4942
R373 SENSE_CLK.n17 SENSE_CLK.n16 18.4942
R374 SENSE_CLK.n7 SENSE_CLK.n6 18.4942
R375 SENSE_CLK.n12 SENSE_CLK.n11 18.4942
R376 SENSE_CLK.n69 SENSE_CLK.n68 18.4942
R377 SENSE_CLK.n48 SENSE_CLK.n47 18.4942
R378 SENSE_CLK.n49 SENSE_CLK.n39 18.4942
R379 SENSE_CLK.n50 SENSE_CLK.n37 18.4942
R380 SENSE_CLK.n52 SENSE_CLK.n51 18.4942
R381 SENSE_CLK.n98 SENSE_CLK.n97 18.4942
R382 SENSE_CLK.n90 SENSE_CLK.n79 18.4942
R383 SENSE_CLK.n91 SENSE_CLK.n78 18.4942
R384 SENSE_CLK.n92 SENSE_CLK.n77 18.4942
R385 SENSE_CLK.n93 SENSE_CLK.n76 18.4942
R386 SENSE_CLK.n94 SENSE_CLK.n75 18.4942
R387 SENSE_CLK.n95 SENSE_CLK.n74 18.4942
R388 SENSE_CLK.n96 SENSE_CLK.n73 18.4942
R389 SENSE_CLK.n55 SENSE_CLK.n54 15.5548
R390 SENSE_CLK.n100 SENSE_CLK.n99 15.5548
R391 SENSE_CLK.n64 SENSE_CLK.n63 14.5766
R392 SENSE_CLK SENSE_CLK.n100 13.9118
R393 SENSE_CLK.n31 SENSE_CLK.n30 11.6805
R394 SENSE_CLK.n31 SENSE_CLK.n28 11.6805
R395 SENSE_CLK.n60 SENSE_CLK.n57 11.6805
R396 SENSE_CLK.n61 SENSE_CLK.n60 11.6805
R397 SENSE_CLK.n62 SENSE_CLK.n61 11.6805
R398 SENSE_CLK.n25 SENSE_CLK.n24 11.6805
R399 SENSE_CLK.n24 SENSE_CLK.n2 11.6805
R400 SENSE_CLK.n20 SENSE_CLK.n2 11.6805
R401 SENSE_CLK.n20 SENSE_CLK.n4 11.6805
R402 SENSE_CLK.n16 SENSE_CLK.n4 11.6805
R403 SENSE_CLK.n16 SENSE_CLK.n7 11.6805
R404 SENSE_CLK.n12 SENSE_CLK.n7 11.6805
R405 SENSE_CLK.n12 SENSE_CLK.n9 11.6805
R406 SENSE_CLK.n68 SENSE_CLK.n67 11.6805
R407 SENSE_CLK.n68 SENSE_CLK.n65 11.6805
R408 SENSE_CLK.n49 SENSE_CLK.n48 11.6805
R409 SENSE_CLK.n48 SENSE_CLK.n40 11.6805
R410 SENSE_CLK.n50 SENSE_CLK.n49 11.6805
R411 SENSE_CLK.n51 SENSE_CLK.n50 11.6805
R412 SENSE_CLK.n51 SENSE_CLK.n38 11.6805
R413 SENSE_CLK.n90 SENSE_CLK.n89 11.6805
R414 SENSE_CLK.n91 SENSE_CLK.n90 11.6805
R415 SENSE_CLK.n92 SENSE_CLK.n91 11.6805
R416 SENSE_CLK.n93 SENSE_CLK.n92 11.6805
R417 SENSE_CLK.n94 SENSE_CLK.n93 11.6805
R418 SENSE_CLK.n95 SENSE_CLK.n94 11.6805
R419 SENSE_CLK.n96 SENSE_CLK.n95 11.6805
R420 SENSE_CLK.n97 SENSE_CLK.n96 11.6805
R421 SENSE_CLK.n27 SENSE_CLK.n0 11.1876
R422 SENSE_CLK.n99 SENSE_CLK.n72 11.0376
R423 SENSE_CLK.n54 SENSE_CLK.n35 10.8396
R424 SENSE_CLK.n27 SENSE_CLK.n26 9.3485
R425 SENSE_CLK.n99 SENSE_CLK.n98 9.1985
R426 SENSE_CLK.n54 SENSE_CLK.n53 9.0005
R427 SENSE_CLK.n32 SENSE_CLK.n29 7.17687
R428 SENSE_CLK.n59 SENSE_CLK.n58 7.17687
R429 SENSE_CLK.n11 SENSE_CLK.n10 7.17687
R430 SENSE_CLK.n69 SENSE_CLK.n66 7.17687
R431 SENSE_CLK.n47 SENSE_CLK.n46 7.17687
R432 SENSE_CLK.n88 SENSE_CLK.n79 7.17687
R433 SENSE_CLK.n53 SENSE_CLK.n36 7.05405
R434 SENSE_CLK.n100 SENSE_CLK.n71 4.69615
R435 SENSE_CLK.n38 SENSE_CLK.n36 4.4296
R436 SENSE_CLK.n30 SENSE_CLK.n29 4.42851
R437 SENSE_CLK.n58 SENSE_CLK.n57 4.42851
R438 SENSE_CLK.n10 SENSE_CLK.n9 4.42851
R439 SENSE_CLK.n67 SENSE_CLK.n66 4.42851
R440 SENSE_CLK.n46 SENSE_CLK.n40 4.42851
R441 SENSE_CLK.n89 SENSE_CLK.n88 4.42851
R442 SENSE_CLK.n55 SENSE_CLK.n34 3.32659
R443 SENSE_CLK.n71 SENSE_CLK.n64 2.73963
R444 SENSE_CLK.n64 SENSE_CLK.n55 0.978761
R445 SENSE_CLK.n11 SENSE_CLK.n6 0.1205
R446 SENSE_CLK.n17 SENSE_CLK.n6 0.1205
R447 SENSE_CLK.n18 SENSE_CLK.n17 0.1205
R448 SENSE_CLK.n19 SENSE_CLK.n18 0.1205
R449 SENSE_CLK.n19 SENSE_CLK.n5 0.1205
R450 SENSE_CLK.n5 SENSE_CLK.n1 0.1205
R451 SENSE_CLK.n26 SENSE_CLK.n1 0.1205
R452 SENSE_CLK.n13 SENSE_CLK.n8 0.1205
R453 SENSE_CLK.n14 SENSE_CLK.n13 0.1205
R454 SENSE_CLK.n15 SENSE_CLK.n14 0.1205
R455 SENSE_CLK.n15 SENSE_CLK.n3 0.1205
R456 SENSE_CLK.n21 SENSE_CLK.n3 0.1205
R457 SENSE_CLK.n22 SENSE_CLK.n21 0.1205
R458 SENSE_CLK.n23 SENSE_CLK.n22 0.1205
R459 SENSE_CLK.n23 SENSE_CLK.n0 0.1205
R460 SENSE_CLK.n45 SENSE_CLK.n44 0.1205
R461 SENSE_CLK.n44 SENSE_CLK.n43 0.1205
R462 SENSE_CLK.n43 SENSE_CLK.n42 0.1205
R463 SENSE_CLK.n42 SENSE_CLK.n41 0.1205
R464 SENSE_CLK.n47 SENSE_CLK.n39 0.1205
R465 SENSE_CLK.n39 SENSE_CLK.n37 0.1205
R466 SENSE_CLK.n52 SENSE_CLK.n37 0.1205
R467 SENSE_CLK.n98 SENSE_CLK.n73 0.1205
R468 SENSE_CLK.n74 SENSE_CLK.n73 0.1205
R469 SENSE_CLK.n75 SENSE_CLK.n74 0.1205
R470 SENSE_CLK.n76 SENSE_CLK.n75 0.1205
R471 SENSE_CLK.n77 SENSE_CLK.n76 0.1205
R472 SENSE_CLK.n78 SENSE_CLK.n77 0.1205
R473 SENSE_CLK.n79 SENSE_CLK.n78 0.1205
R474 SENSE_CLK.n80 SENSE_CLK.n72 0.1205
R475 SENSE_CLK.n81 SENSE_CLK.n80 0.1205
R476 SENSE_CLK.n82 SENSE_CLK.n81 0.1205
R477 SENSE_CLK.n83 SENSE_CLK.n82 0.1205
R478 SENSE_CLK.n84 SENSE_CLK.n83 0.1205
R479 SENSE_CLK.n85 SENSE_CLK.n84 0.1205
R480 SENSE_CLK.n86 SENSE_CLK.n85 0.1205
R481 SENSE_CLK.n87 SENSE_CLK.n86 0.1205
R482 SENSE_CLK.n59 SENSE_CLK.n56 0.114816
R483 SENSE_CLK.n41 SENSE_CLK.n35 0.1085
R484 SENSE_CLK.n53 SENSE_CLK.n52 0.1085
R485 SENSE_CLK.n33 SENSE_CLK.n32 0.0785
R486 SENSE_CLK.n70 SENSE_CLK.n69 0.0785
R487 SENSE_CLK.n63 SENSE_CLK.n56 0.0241842
R488 VDD.n81 VDD.n80 166.667
R489 VDD.n72 VDD.n71 166.667
R490 VDD.n39 VDD.n22 166.667
R491 VDD.n31 VDD.n30 166.667
R492 VDD.n71 VDD.t80 120.001
R493 VDD.t112 VDD.n22 120.001
R494 VDD.n56 VDD.t108 113.334
R495 VDD.t76 VDD.t44 113.334
R496 VDD.t51 VDD.t128 113.334
R497 VDD.t102 VDD.n45 113.334
R498 VDD.n83 VDD.n82 106.3
R499 VDD.n29 VDD.n28 106.3
R500 VDD.n72 VDD.t100 80.0005
R501 VDD.n57 VDD.t42 80.0005
R502 VDD.t52 VDD.n44 80.0005
R503 VDD.t82 VDD.n39 80.0005
R504 VDD.n83 VDD.n4 70.0005
R505 VDD.n79 VDD.n4 70.0005
R506 VDD.n79 VDD.n5 70.0005
R507 VDD.n73 VDD.n5 70.0005
R508 VDD.n73 VDD.n9 70.0005
R509 VDD.n65 VDD.n9 70.0005
R510 VDD.n65 VDD.n11 70.0005
R511 VDD.n59 VDD.n11 70.0005
R512 VDD.n59 VDD.n15 70.0005
R513 VDD.n53 VDD.n15 70.0005
R514 VDD.n53 VDD.n16 70.0005
R515 VDD.n47 VDD.n16 70.0005
R516 VDD.n47 VDD.n20 70.0005
R517 VDD.n38 VDD.n20 70.0005
R518 VDD.n38 VDD.n23 70.0005
R519 VDD.n32 VDD.n23 70.0005
R520 VDD.n32 VDD.n27 70.0005
R521 VDD.n28 VDD.n27 70.0005
R522 VDD.n82 VDD.n81 66.6672
R523 VDD.n30 VDD.n29 66.6672
R524 VDD.n67 VDD.t110 46.6672
R525 VDD.n40 VDD.t72 46.6672
R526 VDD.t34 VDD.n66 40.0005
R527 VDD.n46 VDD.t58 40.0005
R528 VDD.t86 VDD.n57 26.6672
R529 VDD.n44 VDD.t94 26.6672
R530 VDD.n80 VDD.t0 20.0005
R531 VDD.n31 VDD.t120 20.0005
R532 VDD.n93 VDD.n92 19.9029
R533 VDD.n134 VDD.n133 19.8556
R534 VDD.n101 VDD.n100 19.4435
R535 VDD.n165 VDD.n164 19.0889
R536 VDD.n105 VDD.n104 19.0179
R537 VDD.n98 VDD.n97 19.0179
R538 VDD.n90 VDD.n89 19.0179
R539 VDD.n161 VDD.n160 19.0179
R540 VDD.n85 VDD.n84 18.1338
R541 VDD.n3 VDD.n2 18.0005
R542 VDD.n78 VDD.n77 18.0005
R543 VDD.n76 VDD.n6 18.0005
R544 VDD.n75 VDD.n74 18.0005
R545 VDD.n8 VDD.n7 18.0005
R546 VDD.n64 VDD.n63 18.0005
R547 VDD.n62 VDD.n12 18.0005
R548 VDD.n61 VDD.n60 18.0005
R549 VDD.n14 VDD.n13 18.0005
R550 VDD.n52 VDD.n51 18.0005
R551 VDD.n50 VDD.n17 18.0005
R552 VDD.n49 VDD.n48 18.0005
R553 VDD.n19 VDD.n18 18.0005
R554 VDD.n37 VDD.n36 18.0005
R555 VDD.n35 VDD.n24 18.0005
R556 VDD.n34 VDD.n33 18.0005
R557 VDD.n29 VDD.n21 17.6387
R558 VDD.n128 VDD.n127 16.6701
R559 VDD.n139 VDD.n138 16.6701
R560 VDD.n82 VDD.n1 16.3758
R561 VDD.n71 VDD.n70 16.3758
R562 VDD.n69 VDD.n68 16.3758
R563 VDD.n57 VDD.n10 16.3758
R564 VDD.n44 VDD.n43 16.3758
R565 VDD.n42 VDD.n41 16.3758
R566 VDD.n22 VDD.n21 16.3758
R567 VDD.n123 VDD.n122 14.4407
R568 VDD.n143 VDD.n142 14.3222
R569 VDD.t88 VDD.t0 13.3338
R570 VDD.t80 VDD.t88 13.3338
R571 VDD.t114 VDD.t100 13.3338
R572 VDD.t124 VDD.t114 13.3338
R573 VDD.t110 VDD.t124 13.3338
R574 VDD.t10 VDD.t12 13.3338
R575 VDD.t18 VDD.t10 13.3338
R576 VDD.t22 VDD.t18 13.3338
R577 VDD.t24 VDD.t22 13.3338
R578 VDD.n66 VDD.t106 13.3338
R579 VDD.t84 VDD.t106 13.3338
R580 VDD.t74 VDD.t84 13.3338
R581 VDD.t108 VDD.t74 13.3338
R582 VDD.t36 VDD.n56 13.3338
R583 VDD.t38 VDD.t36 13.3338
R584 VDD.t40 VDD.t38 13.3338
R585 VDD.t42 VDD.t40 13.3338
R586 VDD.t44 VDD.t45 13.3338
R587 VDD.t45 VDD.t46 13.3338
R588 VDD.t46 VDD.t47 13.3338
R589 VDD.t48 VDD.t49 13.3338
R590 VDD.t49 VDD.t50 13.3338
R591 VDD.t50 VDD.t51 13.3338
R592 VDD.t54 VDD.t52 13.3338
R593 VDD.t56 VDD.t54 13.3338
R594 VDD.t20 VDD.t56 13.3338
R595 VDD.n45 VDD.t20 13.3338
R596 VDD.t118 VDD.t102 13.3338
R597 VDD.t122 VDD.t118 13.3338
R598 VDD.t4 VDD.t122 13.3338
R599 VDD.n46 VDD.t4 13.3338
R600 VDD.t66 VDD.t64 13.3338
R601 VDD.t64 VDD.t68 13.3338
R602 VDD.t68 VDD.t14 13.3338
R603 VDD.t14 VDD.t16 13.3338
R604 VDD.t72 VDD.t2 13.3338
R605 VDD.t2 VDD.t90 13.3338
R606 VDD.t90 VDD.t82 13.3338
R607 VDD.t116 VDD.t112 13.3338
R608 VDD.t120 VDD.t116 13.3338
R609 VDD.n34 VDD.n25 9.31191
R610 VDD.n115 VDD.n114 8.55306
R611 VDD.n153 VDD.n152 8.42404
R612 VDD.n28 VDD.n25 6.79358
R613 VDD.t12 VDD.n67 6.66717
R614 VDD.n68 VDD.t24 6.66717
R615 VDD.n68 VDD.t26 6.66717
R616 VDD.t26 VDD.t92 6.66717
R617 VDD.t92 VDD.t28 6.66717
R618 VDD.t28 VDD.t130 6.66717
R619 VDD.t130 VDD.t30 6.66717
R620 VDD.t30 VDD.t96 6.66717
R621 VDD.t96 VDD.t32 6.66717
R622 VDD.t32 VDD.t126 6.66717
R623 VDD.t126 VDD.t34 6.66717
R624 VDD.n58 VDD.t86 6.66717
R625 VDD.n58 VDD.t76 6.66717
R626 VDD.t47 VDD.n55 6.66717
R627 VDD.n55 VDD.t48 6.66717
R628 VDD.t128 VDD.n54 6.66717
R629 VDD.n54 VDD.t94 6.66717
R630 VDD.t98 VDD.t58 6.66717
R631 VDD.t6 VDD.t98 6.66717
R632 VDD.t78 VDD.t6 6.66717
R633 VDD.t60 VDD.t78 6.66717
R634 VDD.t70 VDD.t60 6.66717
R635 VDD.t8 VDD.t70 6.66717
R636 VDD.t104 VDD.t8 6.66717
R637 VDD.t62 VDD.t104 6.66717
R638 VDD.n41 VDD.t62 6.66717
R639 VDD.n41 VDD.t66 6.66717
R640 VDD.t16 VDD.n40 6.66717
R641 VDD.n84 VDD.n83 6.3005
R642 VDD.n81 VDD.n4 6.3005
R643 VDD.n4 VDD.n3 6.3005
R644 VDD.n80 VDD.n79 6.3005
R645 VDD.n79 VDD.n78 6.3005
R646 VDD.n71 VDD.n5 6.3005
R647 VDD.n6 VDD.n5 6.3005
R648 VDD.n73 VDD.n72 6.3005
R649 VDD.n74 VDD.n73 6.3005
R650 VDD.n67 VDD.n9 6.3005
R651 VDD.n9 VDD.n8 6.3005
R652 VDD.n66 VDD.n65 6.3005
R653 VDD.n65 VDD.n64 6.3005
R654 VDD.n56 VDD.n11 6.3005
R655 VDD.n12 VDD.n11 6.3005
R656 VDD.n59 VDD.n58 6.3005
R657 VDD.n60 VDD.n59 6.3005
R658 VDD.n55 VDD.n15 6.3005
R659 VDD.n15 VDD.n14 6.3005
R660 VDD.n54 VDD.n53 6.3005
R661 VDD.n53 VDD.n52 6.3005
R662 VDD.n45 VDD.n16 6.3005
R663 VDD.n17 VDD.n16 6.3005
R664 VDD.n47 VDD.n46 6.3005
R665 VDD.n48 VDD.n47 6.3005
R666 VDD.n40 VDD.n20 6.3005
R667 VDD.n20 VDD.n19 6.3005
R668 VDD.n39 VDD.n38 6.3005
R669 VDD.n38 VDD.n37 6.3005
R670 VDD.n23 VDD.n22 6.3005
R671 VDD.n24 VDD.n23 6.3005
R672 VDD.n32 VDD.n31 6.3005
R673 VDD.n33 VDD.n32 6.3005
R674 VDD.n30 VDD.n27 6.3005
R675 VDD.n27 VDD.n26 6.3005
R676 VDD.n100 VDD.t121 5.54817
R677 VDD.n164 VDD.t81 5.54817
R678 VDD.n100 VDD.n99 5.51014
R679 VDD.n104 VDD.n103 5.51014
R680 VDD.n108 VDD.n106 5.51014
R681 VDD.n122 VDD.n120 5.51014
R682 VDD.n127 VDD.n126 5.51014
R683 VDD.n138 VDD.n137 5.51014
R684 VDD.n142 VDD.n141 5.51014
R685 VDD.n146 VDD.n144 5.51014
R686 VDD.n89 VDD.n88 5.51014
R687 VDD.n160 VDD.n159 5.51014
R688 VDD.n164 VDD.n163 5.51014
R689 VDD.n97 VDD.n95 5.43909
R690 VDD.n97 VDD.n96 5.39172
R691 VDD.n104 VDD.n102 5.32067
R692 VDD.n114 VDD.n113 5.32067
R693 VDD.n112 VDD.n111 5.32067
R694 VDD.n110 VDD.n109 5.32067
R695 VDD.n108 VDD.n107 5.32067
R696 VDD.n122 VDD.n121 5.32067
R697 VDD.n127 VDD.n125 5.32067
R698 VDD.n138 VDD.n136 5.32067
R699 VDD.n142 VDD.n140 5.32067
R700 VDD.n152 VDD.n151 5.32067
R701 VDD.n150 VDD.n149 5.32067
R702 VDD.n148 VDD.n147 5.32067
R703 VDD.n146 VDD.n145 5.32067
R704 VDD.n89 VDD.n87 5.32067
R705 VDD.n160 VDD.n158 5.32067
R706 VDD.n168 VDD.n0 4.5005
R707 VDD.n167 VDD.n166 4.5005
R708 VDD.n162 VDD.n86 4.5005
R709 VDD.n157 VDD.n156 4.5005
R710 VDD.n155 VDD.n154 4.5005
R711 VDD.n135 VDD.n91 4.5005
R712 VDD.n132 VDD.n131 4.5005
R713 VDD.n130 VDD.n129 4.5005
R714 VDD.n124 VDD.n94 4.5005
R715 VDD.n119 VDD.n118 4.5005
R716 VDD.n117 VDD.n116 4.5005
R717 VDD.n170 VDD.n0 3.0937
R718 VDD.n117 VDD.n101 1.76125
R719 VDD.n105 VDD.n101 1.39974
R720 VDD.n70 VDD.n1 1.26366
R721 VDD.n70 VDD.n69 1.26366
R722 VDD.n69 VDD.n10 1.26366
R723 VDD.n43 VDD.n10 1.26366
R724 VDD.n43 VDD.n42 1.26366
R725 VDD.n42 VDD.n21 1.26366
R726 VDD.n84 VDD.n3 1.0005
R727 VDD.n78 VDD.n3 1.0005
R728 VDD.n78 VDD.n6 1.0005
R729 VDD.n74 VDD.n6 1.0005
R730 VDD.n74 VDD.n8 1.0005
R731 VDD.n64 VDD.n8 1.0005
R732 VDD.n64 VDD.n12 1.0005
R733 VDD.n60 VDD.n12 1.0005
R734 VDD.n60 VDD.n14 1.0005
R735 VDD.n52 VDD.n14 1.0005
R736 VDD.n52 VDD.n17 1.0005
R737 VDD.n48 VDD.n17 1.0005
R738 VDD.n48 VDD.n19 1.0005
R739 VDD.n37 VDD.n19 1.0005
R740 VDD.n37 VDD.n24 1.0005
R741 VDD.n33 VDD.n24 1.0005
R742 VDD.n33 VDD.n26 1.0005
R743 VDD.n166 VDD.n162 0.9005
R744 VDD.n132 VDD.n93 0.8855
R745 VDD.n129 VDD.n128 0.8105
R746 VDD.n143 VDD.n139 0.7505
R747 VDD.n165 VDD.n0 0.7355
R748 VDD.n124 VDD.n123 0.7355
R749 VDD.n162 VDD.n161 0.6605
R750 VDD.n115 VDD.n98 0.622051
R751 VDD.n135 VDD.n134 0.5855
R752 VDD.n157 VDD.n90 0.5105
R753 VDD.n26 VDD.n25 0.481712
R754 VDD.n77 VDD.n2 0.444944
R755 VDD.n77 VDD.n76 0.444944
R756 VDD.n76 VDD.n75 0.444944
R757 VDD.n75 VDD.n7 0.444944
R758 VDD.n63 VDD.n7 0.444944
R759 VDD.n63 VDD.n62 0.444944
R760 VDD.n62 VDD.n61 0.444944
R761 VDD.n61 VDD.n13 0.444944
R762 VDD.n51 VDD.n13 0.444944
R763 VDD.n51 VDD.n50 0.444944
R764 VDD.n50 VDD.n49 0.444944
R765 VDD.n49 VDD.n18 0.444944
R766 VDD.n36 VDD.n18 0.444944
R767 VDD.n36 VDD.n35 0.444944
R768 VDD.n35 VDD.n34 0.444944
R769 VDD.n168 VDD.n167 0.4005
R770 VDD.n167 VDD.n86 0.4005
R771 VDD.n156 VDD.n86 0.4005
R772 VDD.n156 VDD.n155 0.4005
R773 VDD.n155 VDD.n91 0.4005
R774 VDD.n131 VDD.n91 0.4005
R775 VDD.n131 VDD.n130 0.4005
R776 VDD.n130 VDD.n94 0.4005
R777 VDD.n118 VDD.n94 0.4005
R778 VDD.n118 VDD.n117 0.4005
R779 VDD.n169 VDD.n168 0.367167
R780 VDD.n134 VDD.n132 0.3155
R781 VDD.n85 VDD.n2 0.311611
R782 VDD.n169 VDD.n1 0.264711
R783 VDD.n154 VDD.n153 0.256124
R784 VDD.n161 VDD.n157 0.2405
R785 VDD.n99 VDD.t113 0.228
R786 VDD.n99 VDD.t117 0.228
R787 VDD.n102 VDD.t91 0.228
R788 VDD.n102 VDD.t83 0.228
R789 VDD.n103 VDD.t73 0.228
R790 VDD.n103 VDD.t3 0.228
R791 VDD.n113 VDD.t15 0.228
R792 VDD.n113 VDD.t17 0.228
R793 VDD.n111 VDD.t65 0.228
R794 VDD.n111 VDD.t69 0.228
R795 VDD.n109 VDD.t63 0.228
R796 VDD.n109 VDD.t67 0.228
R797 VDD.n107 VDD.t61 0.228
R798 VDD.n107 VDD.t9 0.228
R799 VDD.n106 VDD.t59 0.228
R800 VDD.n106 VDD.t7 0.228
R801 VDD.n95 VDD.t71 0.228
R802 VDD.n95 VDD.t105 0.228
R803 VDD.n96 VDD.t99 0.228
R804 VDD.n96 VDD.t79 0.228
R805 VDD.n121 VDD.t123 0.228
R806 VDD.n121 VDD.t5 0.228
R807 VDD.n120 VDD.t103 0.228
R808 VDD.n120 VDD.t119 0.228
R809 VDD.n125 VDD.t57 0.228
R810 VDD.n125 VDD.t21 0.228
R811 VDD.n126 VDD.t53 0.228
R812 VDD.n126 VDD.t55 0.228
R813 VDD.n92 VDD.t129 0.228
R814 VDD.n92 VDD.t95 0.228
R815 VDD.n133 VDD.t87 0.228
R816 VDD.n133 VDD.t77 0.228
R817 VDD.n136 VDD.t41 0.228
R818 VDD.n136 VDD.t43 0.228
R819 VDD.n137 VDD.t37 0.228
R820 VDD.n137 VDD.t39 0.228
R821 VDD.n140 VDD.t75 0.228
R822 VDD.n140 VDD.t109 0.228
R823 VDD.n141 VDD.t107 0.228
R824 VDD.n141 VDD.t85 0.228
R825 VDD.n151 VDD.t33 0.228
R826 VDD.n151 VDD.t35 0.228
R827 VDD.n149 VDD.t29 0.228
R828 VDD.n149 VDD.t31 0.228
R829 VDD.n147 VDD.t25 0.228
R830 VDD.n147 VDD.t27 0.228
R831 VDD.n145 VDD.t19 0.228
R832 VDD.n145 VDD.t23 0.228
R833 VDD.n144 VDD.t13 0.228
R834 VDD.n144 VDD.t11 0.228
R835 VDD.n87 VDD.t97 0.228
R836 VDD.n87 VDD.t127 0.228
R837 VDD.n88 VDD.t93 0.228
R838 VDD.n88 VDD.t131 0.228
R839 VDD.n158 VDD.t125 0.228
R840 VDD.n158 VDD.t111 0.228
R841 VDD.n159 VDD.t101 0.228
R842 VDD.n159 VDD.t115 0.228
R843 VDD.n163 VDD.t1 0.228
R844 VDD.n163 VDD.t89 0.228
R845 VDD.n110 VDD.n108 0.189974
R846 VDD.n112 VDD.n110 0.189974
R847 VDD.n114 VDD.n112 0.189974
R848 VDD.n148 VDD.n146 0.189974
R849 VDD.n150 VDD.n148 0.189974
R850 VDD.n152 VDD.n150 0.189974
R851 VDD.n166 VDD.n165 0.1655
R852 VDD.n123 VDD.n119 0.1655
R853 VDD.n116 VDD.n115 0.143825
R854 VDD.n119 VDD.n98 0.1355
R855 VDD.n153 VDD.n90 0.135448
R856 VDD.n169 VDD.n85 0.124184
R857 VDD.n139 VDD.n135 0.0905
R858 VDD.n128 VDD.n124 0.0905
R859 VDD.n154 VDD.n143 0.0605
R860 VDD.n116 VDD.n105 0.0605
R861 VDD.n129 VDD.n93 0.0155
R862 VDD VDD.n170 0.0102388
R863 VDD.n170 VDD.n169 0.0100576
R864 VSS.n125 VSS.n88 325
R865 VSS.n131 VSS.n88 325
R866 VSS.n58 VSS.n19 325
R867 VSS.n52 VSS.n19 325
R868 VSS.n80 VSS.t52 247
R869 VSS.n73 VSS.t161 247
R870 VSS.t70 VSS.n132 234
R871 VSS.n59 VSS.t82 234
R872 VSS.n132 VSS.t76 221
R873 VSS.n59 VSS.t40 221
R874 VSS.n84 VSS.t50 182
R875 VSS.t144 VSS.t0 169
R876 VSS.t20 VSS.t148 169
R877 VSS.n125 VSS.n124 149.5
R878 VSS.n52 VSS.n23 149.5
R879 VSS.n139 VSS.t140 117.001
R880 VSS.n8 VSS.t150 117.001
R881 VSS.n47 VSS.n24 87.5005
R882 VSS.n43 VSS.n41 87.5005
R883 VSS.n41 VSS.n40 87.5005
R884 VSS.n38 VSS.n27 87.5005
R885 VSS.n34 VSS.n27 87.5005
R886 VSS.n32 VSS.n31 87.5005
R887 VSS.n103 VSS.n92 87.5005
R888 VSS.n103 VSS.n87 87.5005
R889 VSS.n87 VSS.n86 87.5005
R890 VSS.n86 VSS.n85 87.5005
R891 VSS.n85 VSS.n79 87.5005
R892 VSS.n140 VSS.n79 87.5005
R893 VSS.n140 VSS.n10 87.5005
R894 VSS.n144 VSS.n10 87.5005
R895 VSS.n144 VSS.n9 87.5005
R896 VSS.n9 VSS.n2 87.5005
R897 VSS.n74 VSS.n2 87.5005
R898 VSS.n74 VSS.n12 87.5005
R899 VSS.n64 VSS.n12 87.5005
R900 VSS.n64 VSS.n16 87.5005
R901 VSS.n60 VSS.n16 87.5005
R902 VSS.n60 VSS.n18 87.5005
R903 VSS.n48 VSS.n18 87.5005
R904 VSS.n51 VSS.n48 87.5005
R905 VSS.n110 VSS.n109 87.5005
R906 VSS.n114 VSS.n113 87.5005
R907 VSS.n118 VSS.n117 87.5005
R908 VSS.n122 VSS.n98 87.5005
R909 VSS.n126 VSS.n89 87.5005
R910 VSS.n130 VSS.n89 87.5005
R911 VSS.n130 VSS.n83 87.5005
R912 VSS.n134 VSS.n83 87.5005
R913 VSS.n134 VSS.n81 87.5005
R914 VSS.n138 VSS.n81 87.5005
R915 VSS.n138 VSS.n7 87.5005
R916 VSS.n145 VSS.n7 87.5005
R917 VSS.n145 VSS.n4 87.5005
R918 VSS.n149 VSS.n4 87.5005
R919 VSS.n149 VSS.n3 87.5005
R920 VSS.n71 VSS.n3 87.5005
R921 VSS.n71 VSS.n13 87.5005
R922 VSS.n67 VSS.n13 87.5005
R923 VSS.n67 VSS.n15 87.5005
R924 VSS.n57 VSS.n15 87.5005
R925 VSS.n57 VSS.n20 87.5005
R926 VSS.n53 VSS.n20 87.5005
R927 VSS.n51 VSS.n47 68.2505
R928 VSS.n106 VSS.n92 68.2505
R929 VSS.t0 VSS.n84 65.0005
R930 VSS.t148 VSS.n65 65.0005
R931 VSS.n126 VSS.n91 50.7505
R932 VSS.n53 VSS.n22 50.7505
R933 VSS.n151 VSS.n1 29.6637
R934 VSS.n151 VSS.n150 28.4005
R935 VSS.n97 VSS.n91 26.2505
R936 VSS.t26 VSS.n131 26.0005
R937 VSS.t24 VSS.t26 26.0005
R938 VSS.t78 VSS.t24 26.0005
R939 VSS.t76 VSS.t78 26.0005
R940 VSS.t32 VSS.t70 26.0005
R941 VSS.t46 VSS.t32 26.0005
R942 VSS.t44 VSS.t46 26.0005
R943 VSS.t136 VSS.t87 26.0005
R944 VSS.t87 VSS.t63 26.0005
R945 VSS.t63 VSS.t144 26.0005
R946 VSS.t50 VSS.t140 26.0005
R947 VSS.t36 VSS.t16 26.0005
R948 VSS.t16 VSS.t30 26.0005
R949 VSS.t30 VSS.t48 26.0005
R950 VSS.t48 VSS.t37 26.0005
R951 VSS.t37 VSS.t17 26.0005
R952 VSS.t17 VSS.t31 26.0005
R953 VSS.t31 VSS.t49 26.0005
R954 VSS.t49 VSS.t73 26.0005
R955 VSS.t73 VSS.t81 26.0005
R956 VSS.t81 VSS.t65 26.0005
R957 VSS.t65 VSS.t135 26.0005
R958 VSS.t54 VSS.t53 26.0005
R959 VSS.t55 VSS.t54 26.0005
R960 VSS.t55 VSS.t56 26.0005
R961 VSS.t57 VSS.t56 26.0005
R962 VSS.t58 VSS.t57 26.0005
R963 VSS.t59 VSS.t58 26.0005
R964 VSS.t60 VSS.t59 26.0005
R965 VSS.t61 VSS.t60 26.0005
R966 VSS.t62 VSS.t61 26.0005
R967 VSS.t4 VSS.t62 26.0005
R968 VSS.t2 VSS.t4 26.0005
R969 VSS.t6 VSS.t2 26.0005
R970 VSS.t8 VSS.t6 26.0005
R971 VSS.t10 VSS.t8 26.0005
R972 VSS.t150 VSS.t151 26.0005
R973 VSS.t151 VSS.t152 26.0005
R974 VSS.t152 VSS.t153 26.0005
R975 VSS.t153 VSS.t154 26.0005
R976 VSS.t154 VSS.t155 26.0005
R977 VSS.t155 VSS.t156 26.0005
R978 VSS.t156 VSS.t157 26.0005
R979 VSS.t158 VSS.t157 26.0005
R980 VSS.t159 VSS.t158 26.0005
R981 VSS.t160 VSS.t159 26.0005
R982 VSS.t115 VSS.t113 26.0005
R983 VSS.t117 VSS.t115 26.0005
R984 VSS.t120 VSS.t117 26.0005
R985 VSS.t34 VSS.t120 26.0005
R986 VSS.t14 VSS.t34 26.0005
R987 VSS.t123 VSS.t14 26.0005
R988 VSS.t127 VSS.t123 26.0005
R989 VSS.t129 VSS.t127 26.0005
R990 VSS.t125 VSS.t129 26.0005
R991 VSS.t131 VSS.t125 26.0005
R992 VSS.t133 VSS.t131 26.0005
R993 VSS.n65 VSS.t133 26.0005
R994 VSS.t142 VSS.t20 26.0005
R995 VSS.t66 VSS.t142 26.0005
R996 VSS.t18 VSS.t66 26.0005
R997 VSS.t74 VSS.t84 26.0005
R998 VSS.t22 VSS.t74 26.0005
R999 VSS.t82 VSS.t22 26.0005
R1000 VSS.t40 VSS.t68 26.0005
R1001 VSS.t68 VSS.t146 26.0005
R1002 VSS.t146 VSS.t138 26.0005
R1003 VSS.t138 VSS.n58 26.0005
R1004 VSS.n225 VSS.t149 23.9124
R1005 VSS.n196 VSS.t1 23.8177
R1006 VSS.n173 VSS.n172 23.8024
R1007 VSS.n182 VSS.n181 23.7551
R1008 VSS.n152 VSS.n0 21.0437
R1009 VSS.n139 VSS.t36 19.5005
R1010 VSS.t135 VSS.n80 19.5005
R1011 VSS.n73 VSS.t86 19.5005
R1012 VSS.t95 VSS.t12 19.5005
R1013 VSS.t97 VSS.t42 19.5005
R1014 VSS.t99 VSS.t38 19.5005
R1015 VSS.t93 VSS.t28 19.5005
R1016 VSS.t91 VSS.t72 19.5005
R1017 VSS.t101 VSS.t13 19.5005
R1018 VSS.t103 VSS.t43 19.5005
R1019 VSS.t105 VSS.t39 19.5005
R1020 VSS.t107 VSS.t29 19.5005
R1021 VSS.t89 VSS.t80 19.5005
R1022 VSS.t109 VSS.t162 19.5005
R1023 VSS.n186 VSS.n185 18.5679
R1024 VSS.n157 VSS.n154 18.2754
R1025 VSS.n195 VSS.n194 18.2754
R1026 VSS.n234 VSS.n233 18.157
R1027 VSS.n163 VSS.n162 18.157
R1028 VSS.n192 VSS.n187 18.157
R1029 VSS.n133 VSS.t44 13.0005
R1030 VSS.n133 VSS.t136 13.0005
R1031 VSS.t52 VSS.n1 13.0005
R1032 VSS.t53 VSS.n1 13.0005
R1033 VSS.n8 VSS.t10 13.0005
R1034 VSS.n150 VSS.t160 13.0005
R1035 VSS.n150 VSS.t161 13.0005
R1036 VSS.t111 VSS.n72 13.0005
R1037 VSS.n72 VSS.t113 13.0005
R1038 VSS.n66 VSS.t18 13.0005
R1039 VSS.n66 VSS.t84 13.0005
R1040 VSS.n224 VSS.n223 11.7005
R1041 VSS.n220 VSS.n207 11.7005
R1042 VSS.n180 VSS.n179 11.7005
R1043 VSS.t86 VSS.t95 6.5005
R1044 VSS.t12 VSS.t97 6.5005
R1045 VSS.t42 VSS.t99 6.5005
R1046 VSS.t38 VSS.t93 6.5005
R1047 VSS.t28 VSS.t91 6.5005
R1048 VSS.t72 VSS.t101 6.5005
R1049 VSS.t13 VSS.t103 6.5005
R1050 VSS.t43 VSS.t105 6.5005
R1051 VSS.t39 VSS.t107 6.5005
R1052 VSS.t29 VSS.t89 6.5005
R1053 VSS.t80 VSS.t109 6.5005
R1054 VSS.t162 VSS.t111 6.5005
R1055 VSS.n179 VSS.t11 5.78141
R1056 VSS.n167 VSS.n165 5.66497
R1057 VSS.n210 VSS.n208 5.66497
R1058 VSS.n178 VSS.n176 5.66497
R1059 VSS.n233 VSS.n232 5.57485
R1060 VSS.n160 VSS.n158 5.57485
R1061 VSS.n190 VSS.n188 5.57485
R1062 VSS.n185 VSS.n184 5.57485
R1063 VSS.n167 VSS.n166 5.4755
R1064 VSS.n169 VSS.n168 5.4755
R1065 VSS.n171 VSS.n170 5.4755
R1066 VSS.n222 VSS.n221 5.4755
R1067 VSS.n220 VSS.n219 5.4755
R1068 VSS.n218 VSS.n217 5.4755
R1069 VSS.n216 VSS.n215 5.4755
R1070 VSS.n214 VSS.n213 5.4755
R1071 VSS.n212 VSS.n211 5.4755
R1072 VSS.n210 VSS.n209 5.4755
R1073 VSS.n178 VSS.n177 5.4755
R1074 VSS.n233 VSS.n231 5.38537
R1075 VSS.n157 VSS.n156 5.38537
R1076 VSS.n162 VSS.n161 5.38537
R1077 VSS.n160 VSS.n159 5.38537
R1078 VSS.n194 VSS.n193 5.38537
R1079 VSS.n192 VSS.n191 5.38537
R1080 VSS.n190 VSS.n189 5.38537
R1081 VSS.n185 VSS.n183 5.38537
R1082 VSS.n52 VSS.n51 5.2005
R1083 VSS.n51 VSS.n50 5.2005
R1084 VSS.n48 VSS.n19 5.2005
R1085 VSS.n49 VSS.n48 5.2005
R1086 VSS.n58 VSS.n18 5.2005
R1087 VSS.n18 VSS.n17 5.2005
R1088 VSS.n60 VSS.n59 5.2005
R1089 VSS.n61 VSS.n60 5.2005
R1090 VSS.n66 VSS.n16 5.2005
R1091 VSS.n62 VSS.n16 5.2005
R1092 VSS.n65 VSS.n64 5.2005
R1093 VSS.n64 VSS.n63 5.2005
R1094 VSS.n72 VSS.n12 5.2005
R1095 VSS.n12 VSS.n11 5.2005
R1096 VSS.n74 VSS.n73 5.2005
R1097 VSS.n75 VSS.n74 5.2005
R1098 VSS.t158 VSS.n2 5.2005
R1099 VSS.n76 VSS.n2 5.2005
R1100 VSS.n9 VSS.n8 5.2005
R1101 VSS.n77 VSS.n9 5.2005
R1102 VSS.t55 VSS.n144 5.2005
R1103 VSS.n144 VSS.n143 5.2005
R1104 VSS.n80 VSS.n10 5.2005
R1105 VSS.n142 VSS.n10 5.2005
R1106 VSS.n140 VSS.n139 5.2005
R1107 VSS.n141 VSS.n140 5.2005
R1108 VSS.n84 VSS.n79 5.2005
R1109 VSS.n79 VSS.n78 5.2005
R1110 VSS.n133 VSS.n85 5.2005
R1111 VSS.n100 VSS.n85 5.2005
R1112 VSS.n132 VSS.n86 5.2005
R1113 VSS.n101 VSS.n86 5.2005
R1114 VSS.n131 VSS.n87 5.2005
R1115 VSS.n102 VSS.n87 5.2005
R1116 VSS.n103 VSS.n88 5.2005
R1117 VSS.n104 VSS.n103 5.2005
R1118 VSS.n125 VSS.n92 5.2005
R1119 VSS.n105 VSS.n92 5.2005
R1120 VSS.n124 VSS.n91 5.2005
R1121 VSS.n91 VSS.n90 5.2005
R1122 VSS.n99 VSS.n97 5.2005
R1123 VSS.n122 VSS.n121 5.2005
R1124 VSS.n120 VSS.n98 5.2005
R1125 VSS.n119 VSS.n118 5.2005
R1126 VSS.n117 VSS.n116 5.2005
R1127 VSS.n115 VSS.n114 5.2005
R1128 VSS.n113 VSS.n112 5.2005
R1129 VSS.n111 VSS.n110 5.2005
R1130 VSS.n109 VSS.n108 5.2005
R1131 VSS.n107 VSS.n106 5.2005
R1132 VSS.n126 VSS.n125 5.2005
R1133 VSS.n127 VSS.n126 5.2005
R1134 VSS.n89 VSS.n88 5.2005
R1135 VSS.n128 VSS.n89 5.2005
R1136 VSS.n131 VSS.n130 5.2005
R1137 VSS.n130 VSS.n129 5.2005
R1138 VSS.n132 VSS.n83 5.2005
R1139 VSS.n83 VSS.n82 5.2005
R1140 VSS.n134 VSS.n133 5.2005
R1141 VSS.n135 VSS.n134 5.2005
R1142 VSS.n84 VSS.n81 5.2005
R1143 VSS.n136 VSS.n81 5.2005
R1144 VSS.n139 VSS.n138 5.2005
R1145 VSS.n138 VSS.n137 5.2005
R1146 VSS.n80 VSS.n7 5.2005
R1147 VSS.n7 VSS.n6 5.2005
R1148 VSS.n145 VSS.t55 5.2005
R1149 VSS.n146 VSS.n145 5.2005
R1150 VSS.n8 VSS.n4 5.2005
R1151 VSS.n147 VSS.n4 5.2005
R1152 VSS.t158 VSS.n149 5.2005
R1153 VSS.n149 VSS.n148 5.2005
R1154 VSS.n73 VSS.n3 5.2005
R1155 VSS.n5 VSS.n3 5.2005
R1156 VSS.n72 VSS.n71 5.2005
R1157 VSS.n71 VSS.n70 5.2005
R1158 VSS.n65 VSS.n13 5.2005
R1159 VSS.n69 VSS.n13 5.2005
R1160 VSS.n67 VSS.n66 5.2005
R1161 VSS.n68 VSS.n67 5.2005
R1162 VSS.n59 VSS.n15 5.2005
R1163 VSS.n15 VSS.n14 5.2005
R1164 VSS.n58 VSS.n57 5.2005
R1165 VSS.n57 VSS.n56 5.2005
R1166 VSS.n20 VSS.n19 5.2005
R1167 VSS.n55 VSS.n20 5.2005
R1168 VSS.n53 VSS.n52 5.2005
R1169 VSS.n54 VSS.n53 5.2005
R1170 VSS.n47 VSS.n23 5.2005
R1171 VSS.n47 VSS.n46 5.2005
R1172 VSS.n45 VSS.n24 5.2005
R1173 VSS.n44 VSS.n43 5.2005
R1174 VSS.n41 VSS.n23 5.2005
R1175 VSS.n41 VSS.n25 5.2005
R1176 VSS.n40 VSS.n26 5.2005
R1177 VSS.n38 VSS.n37 5.2005
R1178 VSS.n27 VSS.n23 5.2005
R1179 VSS.n36 VSS.n27 5.2005
R1180 VSS.n35 VSS.n34 5.2005
R1181 VSS.n32 VSS.n28 5.2005
R1182 VSS.n31 VSS.n30 5.2005
R1183 VSS.n22 VSS.n21 5.2005
R1184 VSS.n123 VSS.n97 4.6486
R1185 VSS.n98 VSS.n96 4.6486
R1186 VSS.n117 VSS.n95 4.6486
R1187 VSS.n113 VSS.n94 4.6486
R1188 VSS.n109 VSS.n93 4.6486
R1189 VSS.n43 VSS.n42 4.6486
R1190 VSS.n40 VSS.n39 4.6486
R1191 VSS.n33 VSS.n32 4.6486
R1192 VSS.n42 VSS.n24 4.6486
R1193 VSS.n39 VSS.n38 4.6486
R1194 VSS.n34 VSS.n33 4.6486
R1195 VSS.n106 VSS.n93 4.6486
R1196 VSS.n110 VSS.n94 4.6486
R1197 VSS.n114 VSS.n95 4.6486
R1198 VSS.n118 VSS.n96 4.6486
R1199 VSS.n123 VSS.n122 4.6486
R1200 VSS.n198 VSS.n197 4.5005
R1201 VSS.n200 VSS.n199 4.5005
R1202 VSS.n201 VSS.n175 4.5005
R1203 VSS.n203 VSS.n202 4.5005
R1204 VSS.n204 VSS.n174 4.5005
R1205 VSS.n206 VSS.n205 4.5005
R1206 VSS.n164 VSS.n155 4.5005
R1207 VSS.n227 VSS.n226 4.5005
R1208 VSS.n229 VSS.n228 4.5005
R1209 VSS.n230 VSS.n153 4.5005
R1210 VSS.n236 VSS.n235 4.5005
R1211 VSS.n152 VSS.n151 4.47524
R1212 VSS.n29 VSS.n22 3.72542
R1213 VSS.n31 VSS.n29 3.72542
R1214 VSS.n235 VSS.n152 2.70392
R1215 VSS.n198 VSS.n186 1.73954
R1216 VSS.n105 VSS.n104 1.1255
R1217 VSS.n104 VSS.n102 1.1255
R1218 VSS.n102 VSS.n101 1.1255
R1219 VSS.n101 VSS.n100 1.1255
R1220 VSS.n100 VSS.n78 1.1255
R1221 VSS.n141 VSS.n78 1.1255
R1222 VSS.n142 VSS.n141 1.1255
R1223 VSS.n143 VSS.n142 1.1255
R1224 VSS.n143 VSS.n77 1.1255
R1225 VSS.n77 VSS.n76 1.1255
R1226 VSS.n76 VSS.n75 1.1255
R1227 VSS.n75 VSS.n11 1.1255
R1228 VSS.n63 VSS.n11 1.1255
R1229 VSS.n63 VSS.n62 1.1255
R1230 VSS.n62 VSS.n61 1.1255
R1231 VSS.n61 VSS.n17 1.1255
R1232 VSS.n49 VSS.n17 1.1255
R1233 VSS.n50 VSS.n49 1.1255
R1234 VSS.n108 VSS.n107 1.1255
R1235 VSS.n111 VSS.n108 1.1255
R1236 VSS.n112 VSS.n111 1.1255
R1237 VSS.n115 VSS.n112 1.1255
R1238 VSS.n116 VSS.n115 1.1255
R1239 VSS.n119 VSS.n116 1.1255
R1240 VSS.n120 VSS.n119 1.1255
R1241 VSS.n121 VSS.n120 1.1255
R1242 VSS.n121 VSS.n99 1.1255
R1243 VSS.n128 VSS.n127 1.1255
R1244 VSS.n129 VSS.n128 1.1255
R1245 VSS.n129 VSS.n82 1.1255
R1246 VSS.n135 VSS.n82 1.1255
R1247 VSS.n136 VSS.n135 1.1255
R1248 VSS.n137 VSS.n136 1.1255
R1249 VSS.n137 VSS.n6 1.1255
R1250 VSS.n146 VSS.n6 1.1255
R1251 VSS.n147 VSS.n146 1.1255
R1252 VSS.n148 VSS.n147 1.1255
R1253 VSS.n148 VSS.n5 1.1255
R1254 VSS.n70 VSS.n5 1.1255
R1255 VSS.n70 VSS.n69 1.1255
R1256 VSS.n69 VSS.n68 1.1255
R1257 VSS.n68 VSS.n14 1.1255
R1258 VSS.n56 VSS.n14 1.1255
R1259 VSS.n56 VSS.n55 1.1255
R1260 VSS.n55 VSS.n54 1.1255
R1261 VSS.n46 VSS.n45 1.1255
R1262 VSS.n45 VSS.n44 1.1255
R1263 VSS.n44 VSS.n25 1.1255
R1264 VSS.n26 VSS.n25 1.1255
R1265 VSS.n37 VSS.n26 1.1255
R1266 VSS.n37 VSS.n36 1.1255
R1267 VSS.n36 VSS.n35 1.1255
R1268 VSS.n35 VSS.n28 1.1255
R1269 VSS.n30 VSS.n28 1.1255
R1270 VSS.n201 VSS.n200 0.9005
R1271 VSS.n202 VSS.n201 0.9005
R1272 VSS.n206 VSS.n174 0.9005
R1273 VSS.n230 VSS.n229 0.9005
R1274 VSS.n107 VSS.n105 0.878
R1275 VSS.n235 VSS.n234 0.8405
R1276 VSS.n207 VSS.n206 0.8105
R1277 VSS.n187 VSS.n186 0.799877
R1278 VSS.n225 VSS.n224 0.7805
R1279 VSS.n29 VSS.n23 0.73879
R1280 VSS.n180 VSS.n174 0.6905
R1281 VSS.n127 VSS.n90 0.653
R1282 VSS.n54 VSS.n21 0.653
R1283 VSS.n197 VSS.n182 0.5855
R1284 VSS.n50 VSS.n0 0.518
R1285 VSS.n226 VSS.n163 0.5105
R1286 VSS.n199 VSS.n198 0.4005
R1287 VSS.n199 VSS.n175 0.4005
R1288 VSS.n203 VSS.n175 0.4005
R1289 VSS.n204 VSS.n203 0.4005
R1290 VSS.n205 VSS.n204 0.4005
R1291 VSS.n205 VSS.n155 0.4005
R1292 VSS.n227 VSS.n155 0.4005
R1293 VSS.n228 VSS.n227 0.4005
R1294 VSS.n228 VSS.n153 0.4005
R1295 VSS.n236 VSS.n153 0.4005
R1296 VSS.n46 VSS.n0 0.3605
R1297 VSS.n99 VSS.n90 0.338
R1298 VSS.n30 VSS.n21 0.338
R1299 VSS.n196 VSS.n195 0.3305
R1300 VSS.n200 VSS.n182 0.3155
R1301 VSS.n124 VSS.n123 0.2772
R1302 VSS.n124 VSS.n96 0.2772
R1303 VSS.n124 VSS.n95 0.2772
R1304 VSS.n124 VSS.n94 0.2772
R1305 VSS.n124 VSS.n93 0.2772
R1306 VSS.n42 VSS.n23 0.2772
R1307 VSS.n39 VSS.n23 0.2772
R1308 VSS.n33 VSS.n23 0.2772
R1309 VSS.n202 VSS.n180 0.2105
R1310 VSS.n231 VSS.t147 0.20525
R1311 VSS.n231 VSS.t139 0.20525
R1312 VSS.n232 VSS.t41 0.20525
R1313 VSS.n232 VSS.t69 0.20525
R1314 VSS.n156 VSS.t23 0.20525
R1315 VSS.n156 VSS.t83 0.20525
R1316 VSS.n161 VSS.t85 0.20525
R1317 VSS.n161 VSS.t75 0.20525
R1318 VSS.n159 VSS.t67 0.20525
R1319 VSS.n159 VSS.t19 0.20525
R1320 VSS.n158 VSS.t21 0.20525
R1321 VSS.n158 VSS.t143 0.20525
R1322 VSS.n172 VSS.t35 0.20525
R1323 VSS.n172 VSS.t15 0.20525
R1324 VSS.n181 VSS.t51 0.20525
R1325 VSS.n181 VSS.t141 0.20525
R1326 VSS.n193 VSS.t64 0.20525
R1327 VSS.n193 VSS.t145 0.20525
R1328 VSS.n191 VSS.t137 0.20525
R1329 VSS.n191 VSS.t88 0.20525
R1330 VSS.n189 VSS.t47 0.20525
R1331 VSS.n189 VSS.t45 0.20525
R1332 VSS.n188 VSS.t71 0.20525
R1333 VSS.n188 VSS.t33 0.20525
R1334 VSS.n183 VSS.t79 0.20525
R1335 VSS.n183 VSS.t77 0.20525
R1336 VSS.n184 VSS.t27 0.20525
R1337 VSS.n184 VSS.t25 0.20525
R1338 VSS.n195 VSS.n187 0.1955
R1339 VSS.n163 VSS.n154 0.1955
R1340 VSS.n229 VSS.n154 0.1955
R1341 VSS.n162 VSS.n160 0.189974
R1342 VSS.n162 VSS.n157 0.189974
R1343 VSS.n212 VSS.n210 0.189974
R1344 VSS.n214 VSS.n212 0.189974
R1345 VSS.n216 VSS.n214 0.189974
R1346 VSS.n218 VSS.n216 0.189974
R1347 VSS.n220 VSS.n218 0.189974
R1348 VSS.n222 VSS.n220 0.189974
R1349 VSS.n171 VSS.n169 0.189974
R1350 VSS.n169 VSS.n167 0.189974
R1351 VSS.n192 VSS.n190 0.189974
R1352 VSS.n194 VSS.n192 0.189974
R1353 VSS.n197 VSS.n196 0.1655
R1354 VSS.n165 VSS.t132 0.1643
R1355 VSS.n165 VSS.t134 0.1643
R1356 VSS.n166 VSS.t130 0.1643
R1357 VSS.n166 VSS.t126 0.1643
R1358 VSS.n168 VSS.t124 0.1643
R1359 VSS.n168 VSS.t128 0.1643
R1360 VSS.n170 VSS.t122 0.1643
R1361 VSS.n170 VSS.t119 0.1643
R1362 VSS.n221 VSS.t118 0.1643
R1363 VSS.n221 VSS.t121 0.1643
R1364 VSS.n219 VSS.t114 0.1643
R1365 VSS.n219 VSS.t116 0.1643
R1366 VSS.n217 VSS.t110 0.1643
R1367 VSS.n217 VSS.t112 0.1643
R1368 VSS.n215 VSS.t108 0.1643
R1369 VSS.n215 VSS.t90 0.1643
R1370 VSS.n213 VSS.t104 0.1643
R1371 VSS.n213 VSS.t106 0.1643
R1372 VSS.n211 VSS.t92 0.1643
R1373 VSS.n211 VSS.t102 0.1643
R1374 VSS.n209 VSS.t100 0.1643
R1375 VSS.n209 VSS.t94 0.1643
R1376 VSS.n208 VSS.t96 0.1643
R1377 VSS.n208 VSS.t98 0.1643
R1378 VSS.n177 VSS.t7 0.1643
R1379 VSS.n177 VSS.t9 0.1643
R1380 VSS.n176 VSS.t5 0.1643
R1381 VSS.n176 VSS.t3 0.1643
R1382 VSS VSS.n236 0.148833
R1383 VSS.n223 VSS.n222 0.118921
R1384 VSS.n224 VSS.n164 0.1055
R1385 VSS.n207 VSS.n173 0.0755
R1386 VSS.n223 VSS.n171 0.0715526
R1387 VSS.n234 VSS.n230 0.0605
R1388 VSS.n179 VSS.n178 0.0478684
R1389 VSS VSS.n152 0.0188333
R1390 VSS.n173 VSS.n164 0.0155
R1391 VSS.n226 VSS.n225 0.0155
R1392 NTAIL.n33 NTAIL.n22 13.0309
R1393 NTAIL.n33 NTAIL.n32 11.5048
R1394 NTAIL.n49 NTAIL.n48 11.5048
R1395 NTAIL.n38 NTAIL.n37 9.03963
R1396 NTAIL.n1 NTAIL.t40 5.82877
R1397 NTAIL.n13 NTAIL.t17 5.82877
R1398 NTAIL.n37 NTAIL.t0 5.78141
R1399 NTAIL.n36 NTAIL.n34 5.66497
R1400 NTAIL.n25 NTAIL.n23 5.57485
R1401 NTAIL.n29 NTAIL.n27 5.57485
R1402 NTAIL.n41 NTAIL.n39 5.57485
R1403 NTAIL.n45 NTAIL.n43 5.57485
R1404 NTAIL.n36 NTAIL.n35 5.4755
R1405 NTAIL.n1 NTAIL.n0 5.4755
R1406 NTAIL.n3 NTAIL.n2 5.4755
R1407 NTAIL.n5 NTAIL.n4 5.4755
R1408 NTAIL.n7 NTAIL.n6 5.4755
R1409 NTAIL.n9 NTAIL.n8 5.4755
R1410 NTAIL.n11 NTAIL.n10 5.4755
R1411 NTAIL.n21 NTAIL.n20 5.4755
R1412 NTAIL.n19 NTAIL.n18 5.4755
R1413 NTAIL.n17 NTAIL.n16 5.4755
R1414 NTAIL.n15 NTAIL.n14 5.4755
R1415 NTAIL.n13 NTAIL.n12 5.4755
R1416 NTAIL.n25 NTAIL.n24 5.38537
R1417 NTAIL.n32 NTAIL.n26 5.38537
R1418 NTAIL.n31 NTAIL.n30 5.38537
R1419 NTAIL.n29 NTAIL.n28 5.38537
R1420 NTAIL.n41 NTAIL.n40 5.38537
R1421 NTAIL.n48 NTAIL.n42 5.38537
R1422 NTAIL.n47 NTAIL.n46 5.38537
R1423 NTAIL.n45 NTAIL.n44 5.38537
R1424 NTAIL.n38 NTAIL.n33 2.27007
R1425 NTAIL.n49 NTAIL.n38 0.86137
R1426 NTAIL.n23 NTAIL.t41 0.20525
R1427 NTAIL.n23 NTAIL.t46 0.20525
R1428 NTAIL.n24 NTAIL.t49 0.20525
R1429 NTAIL.n24 NTAIL.t43 0.20525
R1430 NTAIL.n26 NTAIL.t44 0.20525
R1431 NTAIL.n26 NTAIL.t52 0.20525
R1432 NTAIL.n30 NTAIL.t47 0.20525
R1433 NTAIL.n30 NTAIL.t50 0.20525
R1434 NTAIL.n28 NTAIL.t45 0.20525
R1435 NTAIL.n28 NTAIL.t42 0.20525
R1436 NTAIL.n27 NTAIL.t48 0.20525
R1437 NTAIL.n27 NTAIL.t51 0.20525
R1438 NTAIL.n39 NTAIL.t5 0.20525
R1439 NTAIL.n39 NTAIL.t12 0.20525
R1440 NTAIL.n40 NTAIL.t11 0.20525
R1441 NTAIL.n40 NTAIL.t8 0.20525
R1442 NTAIL.n42 NTAIL.t15 0.20525
R1443 NTAIL.n42 NTAIL.t13 0.20525
R1444 NTAIL.n46 NTAIL.t9 0.20525
R1445 NTAIL.n46 NTAIL.t6 0.20525
R1446 NTAIL.n44 NTAIL.t14 0.20525
R1447 NTAIL.n44 NTAIL.t16 0.20525
R1448 NTAIL.n43 NTAIL.t10 0.20525
R1449 NTAIL.n43 NTAIL.t7 0.20525
R1450 NTAIL.n15 NTAIL.n13 0.189974
R1451 NTAIL.n17 NTAIL.n15 0.189974
R1452 NTAIL.n19 NTAIL.n17 0.189974
R1453 NTAIL.n21 NTAIL.n19 0.189974
R1454 NTAIL.n11 NTAIL.n9 0.189974
R1455 NTAIL.n9 NTAIL.n7 0.189974
R1456 NTAIL.n7 NTAIL.n5 0.189974
R1457 NTAIL.n5 NTAIL.n3 0.189974
R1458 NTAIL.n3 NTAIL.n1 0.189974
R1459 NTAIL.n31 NTAIL.n29 0.189974
R1460 NTAIL.n32 NTAIL.n31 0.189974
R1461 NTAIL.n32 NTAIL.n25 0.189974
R1462 NTAIL.n47 NTAIL.n45 0.189974
R1463 NTAIL.n48 NTAIL.n47 0.189974
R1464 NTAIL.n48 NTAIL.n41 0.189974
R1465 NTAIL.n34 NTAIL.t3 0.1643
R1466 NTAIL.n34 NTAIL.t4 0.1643
R1467 NTAIL.n35 NTAIL.t1 0.1643
R1468 NTAIL.n35 NTAIL.t2 0.1643
R1469 NTAIL.n0 NTAIL.t38 0.1643
R1470 NTAIL.n0 NTAIL.t39 0.1643
R1471 NTAIL.n2 NTAIL.t36 0.1643
R1472 NTAIL.n2 NTAIL.t37 0.1643
R1473 NTAIL.n4 NTAIL.t34 0.1643
R1474 NTAIL.n4 NTAIL.t35 0.1643
R1475 NTAIL.n6 NTAIL.t32 0.1643
R1476 NTAIL.n6 NTAIL.t33 0.1643
R1477 NTAIL.n8 NTAIL.t30 0.1643
R1478 NTAIL.n8 NTAIL.t31 0.1643
R1479 NTAIL.n10 NTAIL.t28 0.1643
R1480 NTAIL.n10 NTAIL.t29 0.1643
R1481 NTAIL.n20 NTAIL.t26 0.1643
R1482 NTAIL.n20 NTAIL.t27 0.1643
R1483 NTAIL.n18 NTAIL.t24 0.1643
R1484 NTAIL.n18 NTAIL.t25 0.1643
R1485 NTAIL.n16 NTAIL.t22 0.1643
R1486 NTAIL.n16 NTAIL.t23 0.1643
R1487 NTAIL.n14 NTAIL.t20 0.1643
R1488 NTAIL.n14 NTAIL.t21 0.1643
R1489 NTAIL.n12 NTAIL.t18 0.1643
R1490 NTAIL.n12 NTAIL.t19 0.1643
R1491 NTAIL.n22 NTAIL.n21 0.0952368
R1492 NTAIL.n22 NTAIL.n11 0.0952368
R1493 NTAIL.n37 NTAIL.n36 0.0478684
R1494 NTAIL NTAIL.n49 0.0396304
R1495 DN.t13 DN.n10 127.788
R1496 DN.t6 DN.n0 127.776
R1497 DN.n10 DN.t12 127.668
R1498 DN.n9 DN.t11 127.668
R1499 DN.n8 DN.t10 127.668
R1500 DN.n7 DN.t9 127.668
R1501 DN.n6 DN.t8 127.668
R1502 DN.t7 DN.n0 127.668
R1503 DN.n11 DN.t13 113.632
R1504 DN.n1 DN.t6 113.629
R1505 DN.t12 DN.n5 109.174
R1506 DN.n13 DN.t11 109.174
R1507 DN.n14 DN.t10 109.174
R1508 DN.n15 DN.t9 109.174
R1509 DN.n16 DN.t8 109.174
R1510 DN.n3 DN.t7 109.174
R1511 DN.n13 DN.n12 18.4942
R1512 DN.n14 DN.n4 18.4942
R1513 DN.n15 DN.n2 18.4942
R1514 DN.n17 DN.n16 18.4942
R1515 DN.n23 DN.n22 14.1606
R1516 DN.n14 DN.n13 11.6805
R1517 DN.n13 DN.n5 11.6805
R1518 DN.n15 DN.n14 11.6805
R1519 DN.n16 DN.n15 11.6805
R1520 DN.n16 DN.n3 11.6805
R1521 DN.n19 DN.n0 10.8201
R1522 DN.n25 DN.n24 10.5266
R1523 DN.n19 DN.n18 9.02007
R1524 DN.n23 DN.n19 7.2005
R1525 DN.n12 DN.n11 7.17687
R1526 DN.n18 DN.n1 7.05405
R1527 DN.n24 DN.t1 5.7796
R1528 DN.n21 DN.t4 5.73764
R1529 DN.n24 DN.t3 5.59012
R1530 DN.n22 DN.t5 5.54817
R1531 DN.n21 DN.n20 5.32067
R1532 DN.n3 DN.n1 4.4296
R1533 DN.n11 DN.n5 4.42851
R1534 DN.n25 DN.n23 0.978761
R1535 DN.n20 DN.t2 0.228
R1536 DN.n20 DN.t0 0.228
R1537 DN.n22 DN.n21 0.189974
R1538 DN.n10 DN.n9 0.1205
R1539 DN.n9 DN.n8 0.1205
R1540 DN.n8 DN.n7 0.1205
R1541 DN.n7 DN.n6 0.1205
R1542 DN.n12 DN.n4 0.1205
R1543 DN.n4 DN.n2 0.1205
R1544 DN.n17 DN.n2 0.1205
R1545 DN.n6 DN.n0 0.1085
R1546 DN.n18 DN.n17 0.1085
R1547 DN DN.n25 0.0396304
R1548 DP.t13 DP.n15 127.788
R1549 DP.t6 DP.n5 127.776
R1550 DP.n15 DP.t12 127.668
R1551 DP.n14 DP.t11 127.668
R1552 DP.n13 DP.t10 127.668
R1553 DP.n12 DP.t9 127.668
R1554 DP.n11 DP.t8 127.668
R1555 DP.t7 DP.n5 127.668
R1556 DP.n16 DP.t13 113.632
R1557 DP.n6 DP.t6 113.629
R1558 DP.t12 DP.n10 109.174
R1559 DP.n18 DP.t11 109.174
R1560 DP.n19 DP.t10 109.174
R1561 DP.n20 DP.t9 109.174
R1562 DP.n21 DP.t8 109.174
R1563 DP.n8 DP.t7 109.174
R1564 DP.n18 DP.n17 18.4942
R1565 DP.n19 DP.n9 18.4942
R1566 DP.n20 DP.n7 18.4942
R1567 DP.n22 DP.n21 18.4942
R1568 DP.n4 DP.n3 14.5055
R1569 DP.n4 DP.n0 11.7788
R1570 DP.n19 DP.n18 11.6805
R1571 DP.n18 DP.n10 11.6805
R1572 DP.n20 DP.n19 11.6805
R1573 DP.n21 DP.n20 11.6805
R1574 DP.n21 DP.n8 11.6805
R1575 DP.n24 DP.n5 10.8396
R1576 DP.n24 DP.n23 9.0005
R1577 DP.n17 DP.n16 7.17687
R1578 DP.n23 DP.n6 7.05405
R1579 DP.n2 DP.t4 5.73764
R1580 DP.n0 DP.t2 5.70855
R1581 DP.n0 DP.t3 5.66118
R1582 DP.n3 DP.t0 5.54817
R1583 DP.n2 DP.n1 5.32067
R1584 DP.n25 DP.n24 4.75485
R1585 DP.n8 DP.n6 4.4296
R1586 DP.n16 DP.n10 4.42851
R1587 DP.n25 DP.n4 1.8005
R1588 DP.n1 DP.t5 0.228
R1589 DP.n1 DP.t1 0.228
R1590 DP.n3 DP.n2 0.189974
R1591 DP.n15 DP.n14 0.1205
R1592 DP.n14 DP.n13 0.1205
R1593 DP.n13 DP.n12 0.1205
R1594 DP.n12 DP.n11 0.1205
R1595 DP.n17 DP.n9 0.1205
R1596 DP.n9 DP.n7 0.1205
R1597 DP.n22 DP.n7 0.1205
R1598 DP.n11 DP.n5 0.1085
R1599 DP.n23 DP.n22 0.1085
R1600 DP DP.n25 0.0396304
R1601 NIN.n13 NIN.n12 19.957
R1602 NIN.n13 NIN.n9 12.3657
R1603 NIN.n25 NIN.n24 11.9353
R1604 NIN.n15 NIN.t26 5.7796
R1605 NIN.n21 NIN.t15 5.7796
R1606 NIN.n11 NIN.t3 5.73764
R1607 NIN.n12 NIN.t0 5.6429
R1608 NIN.n2 NIN.n0 5.57485
R1609 NIN.n6 NIN.n4 5.57485
R1610 NIN.n2 NIN.n1 5.38537
R1611 NIN.n9 NIN.n3 5.38537
R1612 NIN.n8 NIN.n7 5.38537
R1613 NIN.n6 NIN.n5 5.38537
R1614 NIN.n15 NIN.n14 5.38537
R1615 NIN.n17 NIN.n16 5.38537
R1616 NIN.n19 NIN.n18 5.38537
R1617 NIN.n23 NIN.n22 5.38537
R1618 NIN.n21 NIN.n20 5.38537
R1619 NIN.n11 NIN.n10 5.32067
R1620 NIN.n25 NIN.n13 1.95702
R1621 NIN.n10 NIN.t1 0.228
R1622 NIN.n10 NIN.t2 0.228
R1623 NIN.n0 NIN.t13 0.20525
R1624 NIN.n0 NIN.t27 0.20525
R1625 NIN.n1 NIN.t9 0.20525
R1626 NIN.n1 NIN.t7 0.20525
R1627 NIN.n3 NIN.t5 0.20525
R1628 NIN.n3 NIN.t11 0.20525
R1629 NIN.n7 NIN.t6 0.20525
R1630 NIN.n7 NIN.t12 0.20525
R1631 NIN.n5 NIN.t10 0.20525
R1632 NIN.n5 NIN.t8 0.20525
R1633 NIN.n4 NIN.t14 0.20525
R1634 NIN.n4 NIN.t4 0.20525
R1635 NIN.n14 NIN.t24 0.20525
R1636 NIN.n14 NIN.t25 0.20525
R1637 NIN.n16 NIN.t22 0.20525
R1638 NIN.n16 NIN.t23 0.20525
R1639 NIN.n18 NIN.t20 0.20525
R1640 NIN.n18 NIN.t21 0.20525
R1641 NIN.n22 NIN.t18 0.20525
R1642 NIN.n22 NIN.t19 0.20525
R1643 NIN.n20 NIN.t16 0.20525
R1644 NIN.n20 NIN.t17 0.20525
R1645 NIN.n23 NIN.n21 0.189974
R1646 NIN.n19 NIN.n17 0.189974
R1647 NIN.n17 NIN.n15 0.189974
R1648 NIN.n8 NIN.n6 0.189974
R1649 NIN.n9 NIN.n8 0.189974
R1650 NIN.n9 NIN.n2 0.189974
R1651 NIN.n24 NIN.n23 0.0952368
R1652 NIN.n24 NIN.n19 0.0952368
R1653 NIN.n12 NIN.n11 0.0952368
R1654 NIN NIN.n25 0.0396304
R1655 NIP.n14 NIP.n13 20.2309
R1656 NIP.n14 NIP.n10 14.1657
R1657 NIP.n25 NIP.n24 10.957
R1658 NIP.n1 NIP.t23 5.7796
R1659 NIP.n7 NIP.t12 5.7796
R1660 NIP.n12 NIP.t3 5.73764
R1661 NIP.n13 NIP.t0 5.6429
R1662 NIP.n17 NIP.n15 5.57485
R1663 NIP.n21 NIP.n19 5.57485
R1664 NIP.n17 NIP.n16 5.38537
R1665 NIP.n24 NIP.n18 5.38537
R1666 NIP.n23 NIP.n22 5.38537
R1667 NIP.n21 NIP.n20 5.38537
R1668 NIP.n1 NIP.n0 5.38537
R1669 NIP.n3 NIP.n2 5.38537
R1670 NIP.n5 NIP.n4 5.38537
R1671 NIP.n9 NIP.n8 5.38537
R1672 NIP.n7 NIP.n6 5.38537
R1673 NIP.n12 NIP.n11 5.32067
R1674 NIP.n25 NIP.n14 1.05702
R1675 NIP.n11 NIP.t1 0.228
R1676 NIP.n11 NIP.t2 0.228
R1677 NIP.n15 NIP.t24 0.20525
R1678 NIP.n15 NIP.t27 0.20525
R1679 NIP.n16 NIP.t25 0.20525
R1680 NIP.n16 NIP.t26 0.20525
R1681 NIP.n18 NIP.t7 0.20525
R1682 NIP.n18 NIP.t11 0.20525
R1683 NIP.n22 NIP.t9 0.20525
R1684 NIP.n22 NIP.t5 0.20525
R1685 NIP.n20 NIP.t6 0.20525
R1686 NIP.n20 NIP.t10 0.20525
R1687 NIP.n19 NIP.t8 0.20525
R1688 NIP.n19 NIP.t4 0.20525
R1689 NIP.n0 NIP.t21 0.20525
R1690 NIP.n0 NIP.t22 0.20525
R1691 NIP.n2 NIP.t19 0.20525
R1692 NIP.n2 NIP.t20 0.20525
R1693 NIP.n4 NIP.t17 0.20525
R1694 NIP.n4 NIP.t18 0.20525
R1695 NIP.n8 NIP.t15 0.20525
R1696 NIP.n8 NIP.t16 0.20525
R1697 NIP.n6 NIP.t13 0.20525
R1698 NIP.n6 NIP.t14 0.20525
R1699 NIP.n9 NIP.n7 0.189974
R1700 NIP.n5 NIP.n3 0.189974
R1701 NIP.n3 NIP.n1 0.189974
R1702 NIP.n23 NIP.n21 0.189974
R1703 NIP.n24 NIP.n23 0.189974
R1704 NIP.n24 NIP.n17 0.189974
R1705 NIP.n10 NIP.n9 0.0952368
R1706 NIP.n10 NIP.n5 0.0952368
R1707 NIP.n13 NIP.n12 0.0952368
R1708 NIP NIP.n25 0.0396304
R1709 HB.n28 HB.t21 142.571
R1710 HB.n5 HB.t17 113.632
R1711 HB.n0 HB.t24 113.632
R1712 HB.n30 HB.t25 113.632
R1713 HB.n7 HB.t19 109.174
R1714 HB.n8 HB.t20 109.174
R1715 HB.n6 HB.t18 109.174
R1716 HB.n1 HB.t23 109.174
R1717 HB.n2 HB.t22 109.174
R1718 HB.n33 HB.t28 109.174
R1719 HB.n32 HB.t27 109.174
R1720 HB.n31 HB.t26 109.174
R1721 HB.n9 HB.n8 18.5179
R1722 HB.n7 HB.n4 18.4942
R1723 HB.n3 HB.n2 18.4942
R1724 HB.n34 HB.n33 18.4942
R1725 HB.n32 HB.n29 18.4942
R1726 HB.n27 HB.n26 17.4527
R1727 HB.n10 HB.n3 16.4663
R1728 HB.n35 HB.n34 15.8194
R1729 HB.n23 HB.t16 15.1863
R1730 HB.n10 HB.n9 14.6157
R1731 HB.n28 HB.n27 13.344
R1732 HB.n22 HB.n21 12.757
R1733 HB.n7 HB.n6 11.6805
R1734 HB.n8 HB.n7 11.6805
R1735 HB.n2 HB.n1 11.6805
R1736 HB.n33 HB.n32 11.6805
R1737 HB.n32 HB.n31 11.6805
R1738 HB.n18 HB.n17 9.43093
R1739 HB.n5 HB.n4 7.17687
R1740 HB.n3 HB.n0 7.17687
R1741 HB.n30 HB.n29 7.17687
R1742 HB.n12 HB.t13 5.7796
R1743 HB.n16 HB.t6 5.7796
R1744 HB.n20 HB.t3 5.73764
R1745 HB.n25 HB.t5 5.73764
R1746 HB.n26 HB.t1 5.71396
R1747 HB.n21 HB.t2 5.6429
R1748 HB.n12 HB.n11 5.38537
R1749 HB.n14 HB.n13 5.38537
R1750 HB.n16 HB.n15 5.38537
R1751 HB.n20 HB.n19 5.32067
R1752 HB.n25 HB.n24 5.32067
R1753 HB.n6 HB.n5 4.42851
R1754 HB.n1 HB.n0 4.42851
R1755 HB.n31 HB.n30 4.42851
R1756 HB.n18 HB.n10 3.48311
R1757 HB.n27 HB.n23 2.34833
R1758 HB.n35 HB.n28 1.17441
R1759 HB.n22 HB.n18 1.17441
R1760 HB.n23 HB.n22 0.587457
R1761 HB.n19 HB.t0 0.228
R1762 HB.n19 HB.t4 0.228
R1763 HB.n24 HB.t14 0.228
R1764 HB.n24 HB.t15 0.228
R1765 HB.n11 HB.t11 0.20525
R1766 HB.n11 HB.t12 0.20525
R1767 HB.n13 HB.t9 0.20525
R1768 HB.n13 HB.t10 0.20525
R1769 HB.n15 HB.t7 0.20525
R1770 HB.n15 HB.t8 0.20525
R1771 HB.n14 HB.n12 0.189974
R1772 HB.n34 HB.n29 0.1205
R1773 HB.n17 HB.n16 0.0952368
R1774 HB.n17 HB.n14 0.0952368
R1775 HB.n21 HB.n20 0.0952368
R1776 HB.n9 HB.n4 0.0785
R1777 HB HB.n35 0.0396304
R1778 HB.n26 HB.n25 0.0241842
R1779 H.n6 H.t17 142.148
R1780 H.n1 H.t25 113.632
R1781 H.n30 H.t18 113.632
R1782 H.n24 H.t28 113.632
R1783 H.n2 H.t24 109.174
R1784 H.n3 H.t23 109.174
R1785 H.n0 H.t22 109.174
R1786 H.n32 H.t20 109.174
R1787 H.n33 H.t21 109.174
R1788 H.n31 H.t19 109.174
R1789 H.n25 H.t27 109.174
R1790 H.n26 H.t26 109.174
R1791 H.n5 H.n0 18.5179
R1792 H.n34 H.n33 18.5179
R1793 H.n4 H.n3 18.4942
R1794 H.n32 H.n29 18.4942
R1795 H.n27 H.n26 18.4942
R1796 H.n10 H.n9 17.7266
R1797 H.n6 H.n5 16.7679
R1798 H.n28 H.n27 16.1533
R1799 H.n11 H.t6 15.3418
R1800 H.n35 H.n34 14.3418
R1801 H.n10 H.n6 13.657
R1802 H.n15 H.n14 13.0309
R1803 H.n3 H.n2 11.6805
R1804 H.n3 H.n0 11.6805
R1805 H.n32 H.n31 11.6805
R1806 H.n33 H.n32 11.6805
R1807 H.n26 H.n25 11.6805
R1808 H.n23 H.n22 9.70485
R1809 H.n4 H.n1 7.17687
R1810 H.n30 H.n29 7.17687
R1811 H.n27 H.n24 7.17687
R1812 H.n17 H.t16 5.7796
R1813 H.n21 H.t9 5.7796
R1814 H.n13 H.t5 5.73764
R1815 H.n8 H.t8 5.73764
R1816 H.n14 H.t2 5.6429
R1817 H.n9 H.t7 5.6429
R1818 H.n17 H.n16 5.38537
R1819 H.n19 H.n18 5.38537
R1820 H.n21 H.n20 5.38537
R1821 H.n13 H.n12 5.32067
R1822 H.n8 H.n7 5.32067
R1823 H.n2 H.n1 4.42851
R1824 H.n31 H.n30 4.42851
R1825 H.n25 H.n24 4.42851
R1826 H.n28 H.n23 2.97441
R1827 H.n11 H.n10 2.73963
R1828 H.n23 H.n15 1.17441
R1829 H.n35 H.n28 0.587457
R1830 H.n15 H.n11 0.391804
R1831 H.n12 H.t3 0.228
R1832 H.n12 H.t4 0.228
R1833 H.n7 H.t1 0.228
R1834 H.n7 H.t0 0.228
R1835 H.n16 H.t14 0.20525
R1836 H.n16 H.t15 0.20525
R1837 H.n18 H.t12 0.20525
R1838 H.n18 H.t13 0.20525
R1839 H.n20 H.t10 0.20525
R1840 H.n20 H.t11 0.20525
R1841 H.n19 H.n17 0.189974
R1842 H.n22 H.n21 0.0952368
R1843 H.n22 H.n19 0.0952368
R1844 H.n14 H.n13 0.0952368
R1845 H.n9 H.n8 0.0952368
R1846 H.n5 H.n4 0.0785
R1847 H.n34 H.n29 0.0785
R1848 H H.n35 0.0396304
R1849 XP.t43 XP.n25 127.788
R1850 XP.t32 XP.n10 127.788
R1851 XP.t34 XP.n7 127.668
R1852 XP.n25 XP.t42 127.668
R1853 XP.n24 XP.t41 127.668
R1854 XP.n23 XP.t40 127.668
R1855 XP.n22 XP.t39 127.668
R1856 XP.n21 XP.t38 127.668
R1857 XP.n20 XP.t37 127.668
R1858 XP.t36 XP.n8 127.668
R1859 XP.n35 XP.t35 127.668
R1860 XP.n10 XP.t33 127.668
R1861 XP.n26 XP.t43 113.632
R1862 XP.n11 XP.t32 113.632
R1863 XP.n1 XP.t53 113.632
R1864 XP.n38 XP.t54 113.632
R1865 XP.n62 XP.t45 113.632
R1866 XP.n65 XP.t49 113.632
R1867 XP.n38 XP.t55 113.603
R1868 XP.n62 XP.t44 113.603
R1869 XP.n13 XP.t34 109.174
R1870 XP.t42 XP.n19 109.174
R1871 XP.n28 XP.t41 109.174
R1872 XP.n29 XP.t40 109.174
R1873 XP.n30 XP.t39 109.174
R1874 XP.n31 XP.t38 109.174
R1875 XP.n32 XP.t37 109.174
R1876 XP.n33 XP.t36 109.174
R1877 XP.t35 XP.n34 109.174
R1878 XP.t33 XP.n9 109.174
R1879 XP.n2 XP.t52 109.174
R1880 XP.n3 XP.t51 109.174
R1881 XP.n4 XP.t50 109.174
R1882 XP.n66 XP.t48 109.174
R1883 XP.n67 XP.t47 109.174
R1884 XP.n64 XP.t46 109.174
R1885 XP.n39 XP.n38 26.8696
R1886 XP.n63 XP.n62 22.8718
R1887 XP.n37 XP.n5 20.2802
R1888 XP.n69 XP.n64 18.5179
R1889 XP.n13 XP.n12 18.4942
R1890 XP.n28 XP.n27 18.4942
R1891 XP.n29 XP.n18 18.4942
R1892 XP.n30 XP.n17 18.4942
R1893 XP.n31 XP.n16 18.4942
R1894 XP.n32 XP.n15 18.4942
R1895 XP.n33 XP.n14 18.4942
R1896 XP.n34 XP.n6 18.4942
R1897 XP.n3 XP.n0 18.4942
R1898 XP.n5 XP.n4 18.4942
R1899 XP.n68 XP.n67 18.4942
R1900 XP.n49 XP.n48 16.6309
R1901 XP.n70 XP.n69 14.8896
R1902 XP.n80 XP.n79 14.2831
R1903 XP.n47 XP.n46 14.2831
R1904 XP.n61 XP.n60 11.7396
R1905 XP.n29 XP.n28 11.6805
R1906 XP.n28 XP.n19 11.6805
R1907 XP.n30 XP.n29 11.6805
R1908 XP.n31 XP.n30 11.6805
R1909 XP.n32 XP.n31 11.6805
R1910 XP.n33 XP.n32 11.6805
R1911 XP.n34 XP.n33 11.6805
R1912 XP.n34 XP.n13 11.6805
R1913 XP.n13 XP.n9 11.6805
R1914 XP.n3 XP.n2 11.6805
R1915 XP.n4 XP.n3 11.6805
R1916 XP.n67 XP.n66 11.6805
R1917 XP.n67 XP.n64 11.6805
R1918 XP.n36 XP.n6 10.8396
R1919 XP.n36 XP.n35 9.0005
R1920 XP.n27 XP.n26 7.17687
R1921 XP.n12 XP.n11 7.17687
R1922 XP.n1 XP.n0 7.17687
R1923 XP.n68 XP.n65 7.17687
R1924 XP.n37 XP.n36 6.94615
R1925 XP.n51 XP.t31 5.7796
R1926 XP.n57 XP.t23 5.7796
R1927 XP.n72 XP.t11 5.73764
R1928 XP.n41 XP.t17 5.73764
R1929 XP.n45 XP.t15 5.73764
R1930 XP.n48 XP.t25 5.66659
R1931 XP.n48 XP.t20 5.61922
R1932 XP.n79 XP.t2 5.57185
R1933 XP.n51 XP.n50 5.38537
R1934 XP.n53 XP.n52 5.38537
R1935 XP.n55 XP.n54 5.38537
R1936 XP.n59 XP.n58 5.38537
R1937 XP.n57 XP.n56 5.38537
R1938 XP.n41 XP.n40 5.32067
R1939 XP.n43 XP.n42 5.32067
R1940 XP.n45 XP.n44 5.32067
R1941 XP.n72 XP.n71 5.32067
R1942 XP.n74 XP.n73 5.32067
R1943 XP.n76 XP.n75 5.32067
R1944 XP.n78 XP.n77 5.32067
R1945 XP.n26 XP.n19 4.42851
R1946 XP.n11 XP.n9 4.42851
R1947 XP.n2 XP.n1 4.42851
R1948 XP.n66 XP.n65 4.42851
R1949 XP.n39 XP.n37 3.71789
R1950 XP.n61 XP.n49 3.13093
R1951 XP.n49 XP.n47 1.76137
R1952 XP.n47 XP.n39 1.72224
R1953 XP.n80 XP.n70 1.33093
R1954 XP.n63 XP.n61 1.01789
R1955 XP.n70 XP.n63 0.391804
R1956 XP.n40 XP.t1 0.228
R1957 XP.n40 XP.t12 0.228
R1958 XP.n42 XP.t16 0.228
R1959 XP.n42 XP.t14 0.228
R1960 XP.n44 XP.t13 0.228
R1961 XP.n44 XP.t0 0.228
R1962 XP.n71 XP.t9 0.228
R1963 XP.n71 XP.t10 0.228
R1964 XP.n73 XP.t7 0.228
R1965 XP.n73 XP.t8 0.228
R1966 XP.n75 XP.t5 0.228
R1967 XP.n75 XP.t6 0.228
R1968 XP.n77 XP.t3 0.228
R1969 XP.n77 XP.t4 0.228
R1970 XP.n50 XP.t30 0.20525
R1971 XP.n50 XP.t28 0.20525
R1972 XP.n52 XP.t27 0.20525
R1973 XP.n52 XP.t29 0.20525
R1974 XP.n54 XP.t19 0.20525
R1975 XP.n54 XP.t22 0.20525
R1976 XP.n58 XP.t26 0.20525
R1977 XP.n58 XP.t24 0.20525
R1978 XP.n56 XP.t18 0.20525
R1979 XP.n56 XP.t21 0.20525
R1980 XP.n78 XP.n76 0.189974
R1981 XP.n76 XP.n74 0.189974
R1982 XP.n74 XP.n72 0.189974
R1983 XP.n43 XP.n41 0.189974
R1984 XP.n59 XP.n57 0.189974
R1985 XP.n55 XP.n53 0.189974
R1986 XP.n53 XP.n51 0.189974
R1987 XP.n79 XP.n78 0.166289
R1988 XP.n10 XP.n7 0.1205
R1989 XP.n25 XP.n24 0.1205
R1990 XP.n24 XP.n23 0.1205
R1991 XP.n23 XP.n22 0.1205
R1992 XP.n22 XP.n21 0.1205
R1993 XP.n21 XP.n20 0.1205
R1994 XP.n20 XP.n8 0.1205
R1995 XP.n27 XP.n18 0.1205
R1996 XP.n18 XP.n17 0.1205
R1997 XP.n17 XP.n16 0.1205
R1998 XP.n16 XP.n15 0.1205
R1999 XP.n15 XP.n14 0.1205
R2000 XP.n5 XP.n0 0.1205
R2001 XP.n12 XP.n6 0.1085
R2002 XP.n35 XP.n7 0.1085
R2003 XP.n35 XP.n8 0.1085
R2004 XP.n14 XP.n6 0.1085
R2005 XP.n46 XP.n45 0.0952368
R2006 XP.n46 XP.n43 0.0952368
R2007 XP.n60 XP.n59 0.0952368
R2008 XP.n60 XP.n55 0.0952368
R2009 XP.n69 XP.n68 0.0785
R2010 XP XP.n80 0.0396304
R2011 XN.t43 XN.n60 127.788
R2012 XN.t32 XN.n45 127.788
R2013 XN.t34 XN.n42 127.668
R2014 XN.n60 XN.t42 127.668
R2015 XN.n59 XN.t41 127.668
R2016 XN.n58 XN.t40 127.668
R2017 XN.n57 XN.t39 127.668
R2018 XN.n56 XN.t38 127.668
R2019 XN.n55 XN.t37 127.668
R2020 XN.t36 XN.n43 127.668
R2021 XN.n70 XN.t35 127.668
R2022 XN.n45 XN.t33 127.668
R2023 XN.n16 XN.t44 113.632
R2024 XN.n10 XN.t46 113.632
R2025 XN.n61 XN.t43 113.632
R2026 XN.n46 XN.t32 113.632
R2027 XN.n39 XN.t51 113.632
R2028 XN.n74 XN.t55 113.632
R2029 XN.n16 XN.t45 113.603
R2030 XN.n39 XN.t50 113.603
R2031 XN.n12 XN.t48 109.174
R2032 XN.n13 XN.t49 109.174
R2033 XN.n11 XN.t47 109.174
R2034 XN.n48 XN.t34 109.174
R2035 XN.t42 XN.n54 109.174
R2036 XN.n63 XN.t41 109.174
R2037 XN.n64 XN.t40 109.174
R2038 XN.n65 XN.t39 109.174
R2039 XN.n66 XN.t38 109.174
R2040 XN.n67 XN.t37 109.174
R2041 XN.n68 XN.t36 109.174
R2042 XN.t35 XN.n69 109.174
R2043 XN.t33 XN.n44 109.174
R2044 XN.n75 XN.t54 109.174
R2045 XN.n76 XN.t53 109.174
R2046 XN.n73 XN.t52 109.174
R2047 XN.n40 XN.n39 26.5957
R2048 XN.n17 XN.n16 23.1457
R2049 XN.n79 XN.n78 19.3114
R2050 XN.n14 XN.n13 18.5179
R2051 XN.n78 XN.n73 18.5179
R2052 XN.n12 XN.n9 18.4942
R2053 XN.n48 XN.n47 18.4942
R2054 XN.n63 XN.n62 18.4942
R2055 XN.n64 XN.n53 18.4942
R2056 XN.n65 XN.n52 18.4942
R2057 XN.n66 XN.n51 18.4942
R2058 XN.n67 XN.n50 18.4942
R2059 XN.n68 XN.n49 18.4942
R2060 XN.n69 XN.n41 18.4942
R2061 XN.n77 XN.n76 18.4942
R2062 XN.n31 XN.n30 16.357
R2063 XN.n15 XN.n8 15.2222
R2064 XN.n15 XN.n14 14.6157
R2065 XN.n38 XN.n37 12.757
R2066 XN.n29 XN.n28 12.0135
R2067 XN.n12 XN.n11 11.6805
R2068 XN.n13 XN.n12 11.6805
R2069 XN.n64 XN.n63 11.6805
R2070 XN.n63 XN.n54 11.6805
R2071 XN.n65 XN.n64 11.6805
R2072 XN.n66 XN.n65 11.6805
R2073 XN.n67 XN.n66 11.6805
R2074 XN.n68 XN.n67 11.6805
R2075 XN.n69 XN.n68 11.6805
R2076 XN.n69 XN.n48 11.6805
R2077 XN.n48 XN.n44 11.6805
R2078 XN.n76 XN.n75 11.6805
R2079 XN.n76 XN.n73 11.6805
R2080 XN.n71 XN.n41 10.8396
R2081 XN.n71 XN.n70 9.0005
R2082 XN.n72 XN.n71 7.22007
R2083 XN.n10 XN.n9 7.17687
R2084 XN.n62 XN.n61 7.17687
R2085 XN.n47 XN.n46 7.17687
R2086 XN.n77 XN.n74 7.17687
R2087 XN.n19 XN.t31 5.7796
R2088 XN.n25 XN.t20 5.7796
R2089 XN.n1 XN.t0 5.73764
R2090 XN.n30 XN.t19 5.73764
R2091 XN.n8 XN.t9 5.6429
R2092 XN.n30 XN.t18 5.54817
R2093 XN.n37 XN.n32 5.51014
R2094 XN.n36 XN.n34 5.51014
R2095 XN.n19 XN.n18 5.38537
R2096 XN.n21 XN.n20 5.38537
R2097 XN.n23 XN.n22 5.38537
R2098 XN.n27 XN.n26 5.38537
R2099 XN.n25 XN.n24 5.38537
R2100 XN.n7 XN.n6 5.32067
R2101 XN.n5 XN.n4 5.32067
R2102 XN.n3 XN.n2 5.32067
R2103 XN.n1 XN.n0 5.32067
R2104 XN.n37 XN.n33 5.32067
R2105 XN.n36 XN.n35 5.32067
R2106 XN.n11 XN.n10 4.42851
R2107 XN.n61 XN.n54 4.42851
R2108 XN.n46 XN.n44 4.42851
R2109 XN.n75 XN.n74 4.42851
R2110 XN.n72 XN.n40 2.93528
R2111 XN.n31 XN.n29 2.93528
R2112 XN.n40 XN.n38 1.72224
R2113 XN.n38 XN.n31 1.64398
R2114 XN.n29 XN.n17 1.33093
R2115 XN.n79 XN.n72 0.783109
R2116 XN.n17 XN.n15 0.391804
R2117 XN.n6 XN.t7 0.228
R2118 XN.n6 XN.t8 0.228
R2119 XN.n4 XN.t5 0.228
R2120 XN.n4 XN.t6 0.228
R2121 XN.n2 XN.t3 0.228
R2122 XN.n2 XN.t4 0.228
R2123 XN.n0 XN.t1 0.228
R2124 XN.n0 XN.t2 0.228
R2125 XN.n32 XN.t16 0.228
R2126 XN.n32 XN.t17 0.228
R2127 XN.n33 XN.t14 0.228
R2128 XN.n33 XN.t15 0.228
R2129 XN.n35 XN.t12 0.228
R2130 XN.n35 XN.t13 0.228
R2131 XN.n34 XN.t10 0.228
R2132 XN.n34 XN.t11 0.228
R2133 XN.n18 XN.t29 0.20525
R2134 XN.n18 XN.t30 0.20525
R2135 XN.n20 XN.t27 0.20525
R2136 XN.n20 XN.t28 0.20525
R2137 XN.n22 XN.t25 0.20525
R2138 XN.n22 XN.t26 0.20525
R2139 XN.n26 XN.t23 0.20525
R2140 XN.n26 XN.t24 0.20525
R2141 XN.n24 XN.t21 0.20525
R2142 XN.n24 XN.t22 0.20525
R2143 XN.n27 XN.n25 0.189974
R2144 XN.n23 XN.n21 0.189974
R2145 XN.n21 XN.n19 0.189974
R2146 XN.n3 XN.n1 0.189974
R2147 XN.n5 XN.n3 0.189974
R2148 XN.n7 XN.n5 0.189974
R2149 XN.n37 XN.n36 0.189974
R2150 XN.n45 XN.n42 0.1205
R2151 XN.n60 XN.n59 0.1205
R2152 XN.n59 XN.n58 0.1205
R2153 XN.n58 XN.n57 0.1205
R2154 XN.n57 XN.n56 0.1205
R2155 XN.n56 XN.n55 0.1205
R2156 XN.n55 XN.n43 0.1205
R2157 XN.n62 XN.n53 0.1205
R2158 XN.n53 XN.n52 0.1205
R2159 XN.n52 XN.n51 0.1205
R2160 XN.n51 XN.n50 0.1205
R2161 XN.n50 XN.n49 0.1205
R2162 XN.n47 XN.n41 0.1085
R2163 XN.n70 XN.n42 0.1085
R2164 XN.n70 XN.n43 0.1085
R2165 XN.n49 XN.n41 0.1085
R2166 XN.n28 XN.n27 0.0952368
R2167 XN.n28 XN.n23 0.0952368
R2168 XN.n8 XN.n7 0.0952368
R2169 XN.n14 XN.n9 0.0785
R2170 XN.n78 XN.n77 0.0785
R2171 XN XN.n79 0.0396304
C0 NIN VDD 6.7829f
C1 NIP SENSE_CLK 2.66751f
C2 NIN INN 2.9203f
C3 VDD CAPTURE_CLK 0.11494f
C4 INP NTAIL 2.88664f
C5 DP XP 2.21809f
C6 DN XN 2.15469f
C7 H INP 0.01521f
C8 OUTN REGEN_CLKB 0.02948f
C9 SENSE_CLK NTAIL 1.36478f
C10 INP INN 4.40194f
C11 H HB 7.51355f
C12 HB VDD 16.1006f
C13 H SENSE_CLK 1.23646f
C14 NIP XN 2.86849f
C15 VDD SENSE_CLK 21.2686f
C16 SENSE_CLK INN 5.49827f
C17 NIN SENSE_BOOST_CLK 0.0301f
C18 REGEN_CLK OUTN 0.01097f
C19 NIN XP 2.21087f
C20 HB DP 0.75819f
C21 H DN 0.66623f
C22 VDD DN 6.18388f
C23 SENSE_CLK DP 0.29923f
C24 INP SENSE_BOOST_CLK 0.07703f
C25 H XN 1.91259f
C26 NIP NTAIL 14.9831f
C27 VDD XN 25.3962f
C28 HB OUTN 1.39766f
C29 SENSE_CLK SENSE_BOOST_CLK 6.47808f
C30 NIP H 0.07824f
C31 HB XP 3.58406f
C32 NIP VDD 6.70406f
C33 SENSE_CLK XP 5.70356f
C34 NIN HB 0.07207f
C35 NIN SENSE_CLK 2.65517f
C36 INN NTAIL 2.17318f
C37 DN XP 0.04432f
C38 H VDD 16.7985f
C39 H INN 0.01521f
C40 XN XP 22.8576f
C41 SENSE_CLK INP 0.42524f
C42 H OUTP 1.28169f
C43 NIP SENSE_BOOST_CLK 0.21857f
C44 HB SENSE_CLK 2.31435f
C45 VDD OUTP 5.18923f
C46 NIN XN 14.5987f
C47 NIP XP 14.5136f
C48 NIP NIN 0.0611f
C49 H DP 2.1383f
C50 SENSE_BOOST_CLK NTAIL 5.37348f
C51 VDD DP 6.18171f
C52 HB DN 2.12721f
C53 VDD REGEN_CLKB 0.13321f
C54 SENSE_CLK DN 0.18071f
C55 INN SENSE_BOOST_CLK 0.07735f
C56 HB XN 0.56886f
C57 H XP 0.82467f
C58 NIN NTAIL 15.4266f
C59 VDD OUTN 5.28554f
C60 NIP INP 2.19392f
C61 SENSE_CLK XN 5.09008f
C62 VDD XP 25.819f
C63 CAPTURE_CLKB VDD 0.11029f
C64 NIN H 0.07949f
C65 NIP HB 0.07069f
C66 REGEN_CLK VDD 0.13916f
C67 CAPTURE_CLK VSS 0.14352f
C68 CAPTURE_CLKB VSS 0.14766f
C69 REGEN_CLK VSS 0.10547f
C70 REGEN_CLKB VSS 0.09145f
C71 SENSE_BOOST_CLK VSS 19.08508f
C72 INN VSS 10.50252f
C73 INP VSS 11.18738f
C74 OUTN VSS 7.39491f
C75 OUTP VSS 7.49786f
C76 SENSE_CLK VSS 17.56661f
C77 VDD VSS 1.39227p
C78 NTAIL VSS 47.09079f
C79 DN VSS 9.84723f
C80 DP VSS 9.85739f
C81 NIN VSS 3.64085f
C82 NIP VSS 3.37521f
C83 HB VSS 19.64067f
C84 H VSS 20.29017f
C85 XP VSS 10.6915f
C86 XN VSS 11.08819f
C87 XN.t9 VSS 1.40222f
C88 XN.t0 VSS 1.41051f
C89 XN.t2 VSS 0.30078f
C90 XN.t1 VSS 0.30078f
C91 XN.n0 VSS 1.06536f
C92 XN.n1 VSS 0.5856f
C93 XN.t4 VSS 0.30078f
C94 XN.t3 VSS 0.30078f
C95 XN.n2 VSS 1.06536f
C96 XN.n3 VSS 0.30569f
C97 XN.t6 VSS 0.30078f
C98 XN.t5 VSS 0.30078f
C99 XN.n4 VSS 1.06536f
C100 XN.n5 VSS 0.30569f
C101 XN.t8 VSS 0.30078f
C102 XN.t7 VSS 0.30078f
C103 XN.n6 VSS 1.06536f
C104 XN.n7 VSS 0.24553f
C105 XN.n8 VSS 1.66647f
C106 XN.n9 VSS 0.32981f
C107 XN.n10 VSS 0.16816f
C108 XN.n11 VSS 0.18026f
C109 XN.n12 VSS 0.18026f
C110 XN.n13 VSS 0.17047f
C111 XN.n14 VSS 0.37781f
C112 XN.n15 VSS 2.16648f
C113 XN.n16 VSS 0.99811f
C114 XN.n17 VSS 1.42782f
C115 XN.t31 VSS 1.44054f
C116 XN.t30 VSS 0.33249f
C117 XN.t29 VSS 0.33249f
C118 XN.n18 VSS 1.05751f
C119 XN.n19 VSS 0.59599f
C120 XN.t28 VSS 0.33249f
C121 XN.t27 VSS 0.33249f
C122 XN.n20 VSS 1.05751f
C123 XN.n21 VSS 0.31355f
C124 XN.t26 VSS 0.33249f
C125 XN.t25 VSS 0.33249f
C126 XN.n22 VSS 1.05751f
C127 XN.n23 VSS 0.25339f
C128 XN.t20 VSS 1.44054f
C129 XN.t22 VSS 0.33249f
C130 XN.t21 VSS 0.33249f
C131 XN.n24 VSS 1.05751f
C132 XN.n25 VSS 0.59599f
C133 XN.t24 VSS 0.33249f
C134 XN.t23 VSS 0.33249f
C135 XN.n26 VSS 1.05751f
C136 XN.n27 VSS 0.25339f
C137 XN.n28 VSS 0.85588f
C138 XN.n29 VSS 1.72783f
C139 XN.t19 VSS 1.48993f
C140 XN.t18 VSS 1.48033f
C141 XN.n30 VSS 2.3154f
C142 XN.n31 VSS 2.81114f
C143 XN.t17 VSS 0.30335f
C144 XN.t16 VSS 0.30078f
C145 XN.n32 VSS 1.0737f
C146 XN.t15 VSS 0.30078f
C147 XN.t14 VSS 0.30078f
C148 XN.n33 VSS 1.06536f
C149 XN.t11 VSS 0.30078f
C150 XN.t10 VSS 0.30336f
C151 XN.n34 VSS 1.0737f
C152 XN.t13 VSS 0.30078f
C153 XN.t12 VSS 0.30078f
C154 XN.n35 VSS 1.06536f
C155 XN.n36 VSS 0.53988f
C156 XN.n37 VSS 1.4484f
C157 XN.n38 VSS 1.69142f
C158 XN.n39 VSS 1.44447f
C159 XN.n40 VSS 3.22051f
C160 XN.n41 VSS 0.24444f
C161 XN.n42 VSS 0.25236f
C162 XN.n43 VSS 0.25236f
C163 XN.n44 VSS 0.18026f
C164 XN.n45 VSS 0.49908f
C165 XN.n46 VSS 0.16816f
C166 XN.n47 VSS 0.33995f
C167 XN.n48 VSS 0.18026f
C168 XN.n49 VSS 0.11663f
C169 XN.n50 VSS 0.11689f
C170 XN.n51 VSS 0.11689f
C171 XN.n52 VSS 0.11689f
C172 XN.n53 VSS 0.11689f
C173 XN.n54 VSS 0.18026f
C174 XN.n55 VSS 0.25263f
C175 XN.n56 VSS 0.25263f
C176 XN.n57 VSS 0.25263f
C177 XN.n58 VSS 0.25263f
C178 XN.n59 VSS 0.25263f
C179 XN.n60 VSS 0.49908f
C180 XN.n61 VSS 0.16816f
C181 XN.n62 VSS 0.34022f
C182 XN.n63 VSS 0.18026f
C183 XN.n64 VSS 0.18026f
C184 XN.n65 VSS 0.18026f
C185 XN.n66 VSS 0.18026f
C186 XN.n67 VSS 0.18026f
C187 XN.n68 VSS 0.18026f
C188 XN.n69 VSS 0.18026f
C189 XN.n70 VSS 0.29816f
C190 XN.n71 VSS 1.89878f
C191 XN.n72 VSS 1.11619f
C192 XN.n73 VSS 0.17047f
C193 XN.n74 VSS 0.16816f
C194 XN.n75 VSS 0.18026f
C195 XN.n76 VSS 0.18026f
C196 XN.n77 VSS 0.32981f
C197 XN.n78 VSS 1.24081f
C198 XN.n79 VSS 1.91047f
C199 XP.n0 VSS 0.33763f
C200 XP.n1 VSS 0.16689f
C201 XP.n2 VSS 0.17889f
C202 XP.n3 VSS 0.17889f
C203 XP.n4 VSS 0.16907f
C204 XP.n5 VSS 1.42202f
C205 XP.n6 VSS 0.24258f
C206 XP.n7 VSS 0.25045f
C207 XP.n8 VSS 0.25045f
C208 XP.n9 VSS 0.17889f
C209 XP.n10 VSS 0.49529f
C210 XP.n11 VSS 0.16689f
C211 XP.n12 VSS 0.33737f
C212 XP.n13 VSS 0.17889f
C213 XP.n14 VSS 0.11574f
C214 XP.n15 VSS 0.116f
C215 XP.n16 VSS 0.116f
C216 XP.n17 VSS 0.116f
C217 XP.n18 VSS 0.116f
C218 XP.n19 VSS 0.17889f
C219 XP.n20 VSS 0.25071f
C220 XP.n21 VSS 0.25071f
C221 XP.n22 VSS 0.25071f
C222 XP.n23 VSS 0.25071f
C223 XP.n24 VSS 0.25071f
C224 XP.n25 VSS 0.49529f
C225 XP.n26 VSS 0.16689f
C226 XP.n27 VSS 0.33763f
C227 XP.n28 VSS 0.17889f
C228 XP.n29 VSS 0.17889f
C229 XP.n30 VSS 0.17889f
C230 XP.n31 VSS 0.17889f
C231 XP.n32 VSS 0.17889f
C232 XP.n33 VSS 0.17889f
C233 XP.n34 VSS 0.17889f
C234 XP.n35 VSS 0.29589f
C235 XP.n36 VSS 1.79642f
C236 XP.n37 VSS 3.10418f
C237 XP.n38 VSS 1.47659f
C238 XP.n39 VSS 3.46011f
C239 XP.t17 VSS 1.40052f
C240 XP.t12 VSS 0.29921f
C241 XP.t1 VSS 0.29921f
C242 XP.n40 VSS 1.05727f
C243 XP.n41 VSS 0.58115f
C244 XP.t14 VSS 0.29921f
C245 XP.t16 VSS 0.29921f
C246 XP.n42 VSS 1.05727f
C247 XP.n43 VSS 0.24367f
C248 XP.t15 VSS 1.40053f
C249 XP.t0 VSS 0.29921f
C250 XP.t13 VSS 0.29921f
C251 XP.n44 VSS 1.05727f
C252 XP.n45 VSS 0.52144f
C253 XP.n46 VSS 1.37337f
C254 XP.n47 VSS 2.05801f
C255 XP.t20 VSS 1.47447f
C256 XP.t25 VSS 1.47688f
C257 XP.n48 VSS 2.36278f
C258 XP.n49 VSS 2.9253f
C259 XP.t31 VSS 1.43159f
C260 XP.t28 VSS 0.3319f
C261 XP.t30 VSS 0.3319f
C262 XP.n50 VSS 1.04947f
C263 XP.n51 VSS 0.59147f
C264 XP.t29 VSS 0.3319f
C265 XP.t27 VSS 0.3319f
C266 XP.n52 VSS 1.04947f
C267 XP.n53 VSS 0.31117f
C268 XP.t22 VSS 0.3319f
C269 XP.t19 VSS 0.3319f
C270 XP.n54 VSS 1.04947f
C271 XP.n55 VSS 0.25146f
C272 XP.t23 VSS 1.43159f
C273 XP.t21 VSS 0.3319f
C274 XP.t18 VSS 0.3319f
C275 XP.n56 VSS 1.04947f
C276 XP.n57 VSS 0.59147f
C277 XP.t24 VSS 0.3319f
C278 XP.t26 VSS 0.3319f
C279 XP.n58 VSS 1.04947f
C280 XP.n59 VSS 0.25146f
C281 XP.n60 VSS 0.78614f
C282 XP.n61 VSS 1.62436f
C283 XP.n62 VSS 0.9546f
C284 XP.n63 VSS 1.25414f
C285 XP.n64 VSS 0.16917f
C286 XP.n65 VSS 0.16689f
C287 XP.n66 VSS 0.17889f
C288 XP.n67 VSS 0.17889f
C289 XP.n68 VSS 0.3273f
C290 XP.n69 VSS 0.42096f
C291 XP.n70 VSS 0.87242f
C292 XP.t11 VSS 1.40053f
C293 XP.t10 VSS 0.29921f
C294 XP.t9 VSS 0.29921f
C295 XP.n71 VSS 1.05727f
C296 XP.n72 VSS 0.58115f
C297 XP.t8 VSS 0.29921f
C298 XP.t7 VSS 0.29921f
C299 XP.n73 VSS 1.05727f
C300 XP.n74 VSS 0.30337f
C301 XP.t6 VSS 0.29921f
C302 XP.t5 VSS 0.29921f
C303 XP.n75 VSS 1.05727f
C304 XP.n76 VSS 0.30337f
C305 XP.t4 VSS 0.29921f
C306 XP.t3 VSS 0.29921f
C307 XP.n77 VSS 1.05727f
C308 XP.n78 VSS 0.28845f
C309 XP.t2 VSS 1.38924f
C310 XP.n79 VSS 1.55537f
C311 XP.n80 VSS 1.57016f
C312 H.n0 VSS 0.11347f
C313 H.n1 VSS 0.11194f
C314 H.n2 VSS 0.11999f
C315 H.n3 VSS 0.11999f
C316 H.n4 VSS 0.21954f
C317 H.n5 VSS 0.44126f
C318 H.n6 VSS 3.4346f
C319 H.t8 VSS 1.04893f
C320 H.t0 VSS 0.31196f
C321 H.t1 VSS 0.31196f
C322 H.n7 VSS 0.70916f
C323 H.n8 VSS 0.34975f
C324 H.t7 VSS 1.04848f
C325 H.n9 VSS 1.6045f
C326 H.n10 VSS 3.91335f
C327 H.t6 VSS 1.23021f
C328 H.n11 VSS 0.73569f
C329 H.t5 VSS 0.99966f
C330 H.t4 VSS 0.26032f
C331 H.t3 VSS 0.26032f
C332 H.n12 VSS 0.70916f
C333 H.n13 VSS 0.34975f
C334 H.t2 VSS 0.99349f
C335 H.n14 VSS 0.87734f
C336 H.n15 VSS 0.88956f
C337 H.t16 VSS 0.94498f
C338 H.t15 VSS 0.20779f
C339 H.t14 VSS 0.20779f
C340 H.n16 VSS 0.70393f
C341 H.n17 VSS 0.39672f
C342 H.t13 VSS 0.20779f
C343 H.t12 VSS 0.20779f
C344 H.n18 VSS 0.70393f
C345 H.n19 VSS 0.16867f
C346 H.t9 VSS 0.94499f
C347 H.t11 VSS 0.20779f
C348 H.t10 VSS 0.20779f
C349 H.n20 VSS 0.70393f
C350 H.n21 VSS 0.35668f
C351 H.n22 VSS 0.21219f
C352 H.n23 VSS 0.77443f
C353 H.n24 VSS 0.11194f
C354 H.n25 VSS 0.11999f
C355 H.n26 VSS 0.1134f
C356 H.n27 VSS 0.64455f
C357 H.n28 VSS 1.08615f
C358 H.n29 VSS 0.21954f
C359 H.n30 VSS 0.11194f
C360 H.n31 VSS 0.11999f
C361 H.n32 VSS 0.11999f
C362 H.n33 VSS 0.11347f
C363 H.n34 VSS 0.22107f
C364 H.n35 VSS 0.30712f
C365 HB.n0 VSS 0.11853f
C366 HB.n1 VSS 0.12706f
C367 HB.n2 VSS 0.12008f
C368 HB.n3 VSS 0.67099f
C369 HB.n4 VSS 0.23247f
C370 HB.n5 VSS 0.11853f
C371 HB.n6 VSS 0.12706f
C372 HB.n7 VSS 0.12706f
C373 HB.n8 VSS 0.12016f
C374 HB.n9 VSS 0.26631f
C375 HB.n10 VSS 1.55606f
C376 HB.t13 VSS 0.99502f
C377 HB.t12 VSS 0.21453f
C378 HB.t11 VSS 0.21453f
C379 HB.n11 VSS 0.74541f
C380 HB.n12 VSS 0.4201f
C381 HB.t10 VSS 0.21453f
C382 HB.t9 VSS 0.21453f
C383 HB.n13 VSS 0.74541f
C384 HB.n14 VSS 0.17861f
C385 HB.t6 VSS 0.99502f
C386 HB.t8 VSS 0.21453f
C387 HB.t7 VSS 0.21453f
C388 HB.n15 VSS 0.74541f
C389 HB.n16 VSS 0.37769f
C390 HB.n17 VSS 0.17978f
C391 HB.n18 VSS 0.85856f
C392 HB.t3 VSS 1.04193f
C393 HB.t4 VSS 0.26153f
C394 HB.t0 VSS 0.26153f
C395 HB.n19 VSS 0.75094f
C396 HB.n20 VSS 0.37036f
C397 HB.t2 VSS 1.04014f
C398 HB.n21 VSS 0.88412f
C399 HB.n22 VSS 0.92915f
C400 HB.t16 VSS 1.31413f
C401 HB.n23 VSS 0.72747f
C402 HB.t1 VSS 1.09797f
C403 HB.t5 VSS 1.10243f
C404 HB.t15 VSS 0.3187f
C405 HB.t14 VSS 0.3187f
C406 HB.n24 VSS 0.75094f
C407 HB.n25 VSS 0.33856f
C408 HB.n26 VSS 1.68303f
C409 HB.n27 VSS 3.98352f
C410 HB.n28 VSS 3.12943f
C411 HB.n29 VSS 0.23981f
C412 HB.n30 VSS 0.11853f
C413 HB.n31 VSS 0.12706f
C414 HB.n32 VSS 0.12706f
C415 HB.n33 VSS 0.12008f
C416 HB.n34 VSS 0.45921f
C417 HB.n35 VSS 0.70772f
C418 NIP.t23 VSS 1.63731f
C419 NIP.t22 VSS 0.30932f
C420 NIP.t21 VSS 0.30932f
C421 NIP.n0 VSS 1.26974f
C422 NIP.n1 VSS 0.71561f
C423 NIP.t20 VSS 0.30932f
C424 NIP.t19 VSS 0.30932f
C425 NIP.n2 VSS 1.26974f
C426 NIP.n3 VSS 0.37648f
C427 NIP.t18 VSS 0.30932f
C428 NIP.t17 VSS 0.30932f
C429 NIP.n4 VSS 1.26974f
C430 NIP.n5 VSS 0.30424f
C431 NIP.t12 VSS 1.63731f
C432 NIP.t14 VSS 0.30932f
C433 NIP.t13 VSS 0.30932f
C434 NIP.n6 VSS 1.26974f
C435 NIP.n7 VSS 0.71561f
C436 NIP.t16 VSS 0.30932f
C437 NIP.t15 VSS 0.30932f
C438 NIP.n8 VSS 1.26974f
C439 NIP.n9 VSS 0.30424f
C440 NIP.n10 VSS 1.29306f
C441 NIP.t3 VSS 1.70663f
C442 NIP.t2 VSS 0.37728f
C443 NIP.t1 VSS 0.37728f
C444 NIP.n11 VSS 1.27917f
C445 NIP.n12 VSS 0.63089f
C446 NIP.t0 VSS 1.70226f
C447 NIP.n13 VSS 3.59374f
C448 NIP.n14 VSS 5.33535f
C449 NIP.t27 VSS 0.37824f
C450 NIP.t24 VSS 0.37477f
C451 NIP.n15 VSS 1.27996f
C452 NIP.t26 VSS 0.37477f
C453 NIP.t25 VSS 0.37477f
C454 NIP.n16 VSS 1.26974f
C455 NIP.n17 VSS 0.66689f
C456 NIP.t11 VSS 0.37477f
C457 NIP.t7 VSS 0.37477f
C458 NIP.n18 VSS 1.26974f
C459 NIP.t4 VSS 0.37477f
C460 NIP.t8 VSS 0.37824f
C461 NIP.n19 VSS 1.27996f
C462 NIP.t10 VSS 0.37477f
C463 NIP.t6 VSS 0.37477f
C464 NIP.n20 VSS 1.26974f
C465 NIP.n21 VSS 0.66689f
C466 NIP.t5 VSS 0.37477f
C467 NIP.t9 VSS 0.37477f
C468 NIP.n22 VSS 1.26974f
C469 NIP.n23 VSS 0.37648f
C470 NIP.n24 VSS 0.96454f
C471 NIP.n25 VSS 0.89411f
C472 NIN.t27 VSS 0.38052f
C473 NIN.t13 VSS 0.37708f
C474 NIN.n0 VSS 1.29695f
C475 NIN.t7 VSS 0.37708f
C476 NIN.t9 VSS 0.37708f
C477 NIN.n1 VSS 1.28659f
C478 NIN.n2 VSS 0.67574f
C479 NIN.t11 VSS 0.37708f
C480 NIN.t5 VSS 0.37708f
C481 NIN.n3 VSS 1.28659f
C482 NIN.t4 VSS 0.37708f
C483 NIN.t14 VSS 0.38052f
C484 NIN.n4 VSS 1.29695f
C485 NIN.t8 VSS 0.37708f
C486 NIN.t10 VSS 0.37708f
C487 NIN.n5 VSS 1.28659f
C488 NIN.n6 VSS 0.67574f
C489 NIN.t12 VSS 0.37708f
C490 NIN.t6 VSS 0.37708f
C491 NIN.n7 VSS 1.28659f
C492 NIN.n8 VSS 0.38148f
C493 NIN.n9 VSS 1.04087f
C494 NIN.t3 VSS 1.72755f
C495 NIN.t2 VSS 0.38056f
C496 NIN.t1 VSS 0.38056f
C497 NIN.n10 VSS 1.29615f
C498 NIN.n11 VSS 0.63926f
C499 NIN.t0 VSS 1.72309f
C500 NIN.n12 VSS 3.5639f
C501 NIN.n13 VSS 5.06885f
C502 NIN.t26 VSS 1.68711f
C503 NIN.t25 VSS 0.34076f
C504 NIN.t24 VSS 0.34076f
C505 NIN.n14 VSS 1.28659f
C506 NIN.n15 VSS 0.7251f
C507 NIN.t23 VSS 0.34076f
C508 NIN.t22 VSS 0.34076f
C509 NIN.n16 VSS 1.28659f
C510 NIN.n17 VSS 0.38148f
C511 NIN.t21 VSS 0.34076f
C512 NIN.t20 VSS 0.34076f
C513 NIN.n18 VSS 1.28659f
C514 NIN.n19 VSS 0.30828f
C515 NIN.t15 VSS 1.68711f
C516 NIN.t17 VSS 0.34076f
C517 NIN.t16 VSS 0.34076f
C518 NIN.n20 VSS 1.28659f
C519 NIN.n21 VSS 0.7251f
C520 NIN.t19 VSS 0.34076f
C521 NIN.t18 VSS 0.34076f
C522 NIN.n22 VSS 1.28659f
C523 NIN.n23 VSS 0.30828f
C524 NIN.n24 VSS 1.01914f
C525 NIN.n25 VSS 1.4376f
C526 DP.t3 VSS 0.89979f
C527 DP.t2 VSS 0.90116f
C528 DP.n0 VSS 0.60387f
C529 DP.t4 VSS 0.90171f
C530 DP.t1 VSS 0.28776f
C531 DP.t5 VSS 0.28776f
C532 DP.n1 VSS 0.59078f
C533 DP.n2 VSS 0.32473f
C534 DP.t0 VSS 0.89974f
C535 DP.n3 VSS 1.08581f
C536 DP.n4 VSS 1.42483f
C537 DP.n5 VSS 0.34607f
C538 DP.n6 VSS 0.09111f
C539 DP.n7 VSS 0.06482f
C540 DP.n8 VSS 0.09996f
C541 DP.n9 VSS 0.06482f
C542 DP.n10 VSS 0.09996f
C543 DP.n11 VSS 0.13994f
C544 DP.n12 VSS 0.14009f
C545 DP.n13 VSS 0.14009f
C546 DP.n14 VSS 0.14009f
C547 DP.n15 VSS 0.27676f
C548 DP.n16 VSS 0.09325f
C549 DP.n17 VSS 0.18866f
C550 DP.n18 VSS 0.09996f
C551 DP.n19 VSS 0.09996f
C552 DP.n20 VSS 0.09996f
C553 DP.n21 VSS 0.09996f
C554 DP.n22 VSS 0.06467f
C555 DP.n23 VSS 0.15109f
C556 DP.n24 VSS 0.54719f
C557 DP.n25 VSS 0.24004f
C558 DN.n0 VSS 0.33878f
C559 DN.n1 VSS 0.0894f
C560 DN.n2 VSS 0.0636f
C561 DN.n3 VSS 0.09808f
C562 DN.n4 VSS 0.0636f
C563 DN.n5 VSS 0.09808f
C564 DN.n6 VSS 0.13732f
C565 DN.n7 VSS 0.13746f
C566 DN.n8 VSS 0.13746f
C567 DN.n9 VSS 0.13746f
C568 DN.n10 VSS 0.27157f
C569 DN.n11 VSS 0.0915f
C570 DN.n12 VSS 0.18512f
C571 DN.n13 VSS 0.09808f
C572 DN.n14 VSS 0.09808f
C573 DN.n15 VSS 0.09808f
C574 DN.n16 VSS 0.09808f
C575 DN.n17 VSS 0.06346f
C576 DN.n18 VSS 0.14833f
C577 DN.n19 VSS 0.61121f
C578 DN.t4 VSS 0.88938f
C579 DN.t0 VSS 0.28695f
C580 DN.t2 VSS 0.28695f
C581 DN.n20 VSS 0.57969f
C582 DN.n21 VSS 0.31864f
C583 DN.t5 VSS 0.88753f
C584 DN.n22 VSS 0.98658f
C585 DN.n23 VSS 1.34081f
C586 DN.t1 VSS 0.89135f
C587 DN.t3 VSS 0.8861f
C588 DN.n24 VSS 0.52459f
C589 DN.n25 VSS 0.3408f
C590 NTAIL.t40 VSS 1.19831f
C591 NTAIL.t39 VSS 0.23354f
C592 NTAIL.t38 VSS 0.23354f
C593 NTAIL.n0 VSS 0.91708f
C594 NTAIL.n1 VSS 0.42963f
C595 NTAIL.t37 VSS 0.23354f
C596 NTAIL.t36 VSS 0.23354f
C597 NTAIL.n2 VSS 0.91708f
C598 NTAIL.n3 VSS 0.22572f
C599 NTAIL.t35 VSS 0.23354f
C600 NTAIL.t34 VSS 0.23354f
C601 NTAIL.n4 VSS 0.91708f
C602 NTAIL.n5 VSS 0.22572f
C603 NTAIL.t33 VSS 0.23354f
C604 NTAIL.t32 VSS 0.23354f
C605 NTAIL.n6 VSS 0.91708f
C606 NTAIL.n7 VSS 0.22572f
C607 NTAIL.t31 VSS 0.23354f
C608 NTAIL.t30 VSS 0.23354f
C609 NTAIL.n8 VSS 0.91708f
C610 NTAIL.n9 VSS 0.22572f
C611 NTAIL.t29 VSS 0.23354f
C612 NTAIL.t28 VSS 0.23354f
C613 NTAIL.n10 VSS 0.91708f
C614 NTAIL.n11 VSS 0.18421f
C615 NTAIL.t17 VSS 1.19831f
C616 NTAIL.t19 VSS 0.23354f
C617 NTAIL.t18 VSS 0.23354f
C618 NTAIL.n12 VSS 0.91708f
C619 NTAIL.n13 VSS 0.42963f
C620 NTAIL.t21 VSS 0.23354f
C621 NTAIL.t20 VSS 0.23354f
C622 NTAIL.n14 VSS 0.91708f
C623 NTAIL.n15 VSS 0.22572f
C624 NTAIL.t23 VSS 0.23354f
C625 NTAIL.t22 VSS 0.23354f
C626 NTAIL.n16 VSS 0.91708f
C627 NTAIL.n17 VSS 0.22572f
C628 NTAIL.t25 VSS 0.23354f
C629 NTAIL.t24 VSS 0.23354f
C630 NTAIL.n18 VSS 0.91708f
C631 NTAIL.n19 VSS 0.22572f
C632 NTAIL.t27 VSS 0.23354f
C633 NTAIL.t26 VSS 0.23354f
C634 NTAIL.n20 VSS 0.91708f
C635 NTAIL.n21 VSS 0.18421f
C636 NTAIL.n22 VSS 0.32601f
C637 NTAIL.t46 VSS 0.23484f
C638 NTAIL.t41 VSS 0.23239f
C639 NTAIL.n23 VSS 0.73564f
C640 NTAIL.t43 VSS 0.23239f
C641 NTAIL.t49 VSS 0.23239f
C642 NTAIL.n24 VSS 0.72977f
C643 NTAIL.n25 VSS 0.38329f
C644 NTAIL.t52 VSS 0.23239f
C645 NTAIL.t44 VSS 0.23239f
C646 NTAIL.n26 VSS 0.72977f
C647 NTAIL.t51 VSS 0.23239f
C648 NTAIL.t48 VSS 0.23484f
C649 NTAIL.n27 VSS 0.73564f
C650 NTAIL.t42 VSS 0.23239f
C651 NTAIL.t45 VSS 0.23239f
C652 NTAIL.n28 VSS 0.72977f
C653 NTAIL.n29 VSS 0.38329f
C654 NTAIL.t50 VSS 0.23239f
C655 NTAIL.t47 VSS 0.23239f
C656 NTAIL.n30 VSS 0.72977f
C657 NTAIL.n31 VSS 0.21638f
C658 NTAIL.n32 VSS 0.64231f
C659 NTAIL.n33 VSS 1.91306f
C660 NTAIL.t4 VSS 0.34097f
C661 NTAIL.t3 VSS 0.33861f
C662 NTAIL.n34 VSS 0.92317f
C663 NTAIL.t2 VSS 0.33861f
C664 NTAIL.t1 VSS 0.33861f
C665 NTAIL.n35 VSS 0.91708f
C666 NTAIL.n36 VSS 0.33949f
C667 NTAIL.t0 VSS 1.30002f
C668 NTAIL.n37 VSS 0.29851f
C669 NTAIL.n38 VSS 0.53273f
C670 NTAIL.t12 VSS 0.20592f
C671 NTAIL.t5 VSS 0.20423f
C672 NTAIL.n39 VSS 0.73564f
C673 NTAIL.t8 VSS 0.20423f
C674 NTAIL.t11 VSS 0.20423f
C675 NTAIL.n40 VSS 0.72977f
C676 NTAIL.n41 VSS 0.38329f
C677 NTAIL.t13 VSS 0.20423f
C678 NTAIL.t15 VSS 0.20423f
C679 NTAIL.n42 VSS 0.72977f
C680 NTAIL.t7 VSS 0.20423f
C681 NTAIL.t10 VSS 0.20592f
C682 NTAIL.n43 VSS 0.73564f
C683 NTAIL.t16 VSS 0.20423f
C684 NTAIL.t14 VSS 0.20423f
C685 NTAIL.n44 VSS 0.72977f
C686 NTAIL.n45 VSS 0.38329f
C687 NTAIL.t6 VSS 0.20423f
C688 NTAIL.t9 VSS 0.20423f
C689 NTAIL.n46 VSS 0.72977f
C690 NTAIL.n47 VSS 0.21638f
C691 NTAIL.n48 VSS 0.64231f
C692 NTAIL.n49 VSS 0.57042f
C693 VSS.t83 VSS 0.07134f
C694 VSS.t23 VSS 0.06945f
C695 VSS.t143 VSS 0.06945f
C696 VSS.t21 VSS 0.07134f
C697 VSS.t19 VSS 0.06945f
C698 VSS.t67 VSS 0.06945f
C699 VSS.t75 VSS 0.06945f
C700 VSS.t85 VSS 0.06945f
C701 VSS.t134 VSS 0.05718f
C702 VSS.t132 VSS 0.056f
C703 VSS.t126 VSS 0.056f
C704 VSS.t130 VSS 0.056f
C705 VSS.t128 VSS 0.056f
C706 VSS.t124 VSS 0.056f
C707 VSS.t119 VSS 0.056f
C708 VSS.t122 VSS 0.056f
C709 VSS.t15 VSS 0.17831f
C710 VSS.t35 VSS 0.17828f
C711 VSS.t11 VSS 0.16343f
C712 VSS.t3 VSS 0.16107f
C713 VSS.t5 VSS 0.16107f
C714 VSS.t9 VSS 0.16107f
C715 VSS.t7 VSS 0.16107f
C716 VSS.t141 VSS 0.17692f
C717 VSS.t51 VSS 0.17696f
C718 VSS.t77 VSS 0.11869f
C719 VSS.t79 VSS 0.11646f
C720 VSS.t25 VSS 0.11646f
C721 VSS.t27 VSS 0.11646f
C722 VSS.t33 VSS 0.07078f
C723 VSS.t71 VSS 0.07271f
C724 VSS.t45 VSS 0.07078f
C725 VSS.t47 VSS 0.07078f
C726 VSS.t88 VSS 0.07078f
C727 VSS.t137 VSS 0.07078f
C728 VSS.t145 VSS 0.0727f
C729 VSS.t64 VSS 0.07078f
C730 VSS.t1 VSS 0.15863f
C731 VSS.t98 VSS 0.056f
C732 VSS.t96 VSS 0.05718f
C733 VSS.t94 VSS 0.056f
C734 VSS.t100 VSS 0.056f
C735 VSS.t102 VSS 0.056f
C736 VSS.t92 VSS 0.056f
C737 VSS.t106 VSS 0.056f
C738 VSS.t104 VSS 0.056f
C739 VSS.t90 VSS 0.056f
C740 VSS.t108 VSS 0.056f
C741 VSS.t112 VSS 0.056f
C742 VSS.t110 VSS 0.056f
C743 VSS.t116 VSS 0.056f
C744 VSS.t114 VSS 0.056f
C745 VSS.t121 VSS 0.056f
C746 VSS.t118 VSS 0.056f
C747 VSS.t149 VSS 0.14375f
C748 VSS.t139 VSS 0.12569f
C749 VSS.t147 VSS 0.12332f
C750 VSS.t69 VSS 0.12332f
C751 VSS.t41 VSS 0.12332f
C752 VDD.n0 VSS 0.21632f
C753 VDD.n1 VSS 0.19651f
C754 VDD.n2 VSS 0.08832f
C755 VDD.n3 VSS 0.10083f
C756 VDD.n4 VSS 0.09645f
C757 VDD.t0 VSS 0.64297f
C758 VDD.n5 VSS 0.09645f
C759 VDD.n6 VSS 0.10083f
C760 VDD.n7 VSS 0.10279f
C761 VDD.n8 VSS 0.10083f
C762 VDD.n9 VSS 0.09645f
C763 VDD.t100 VSS 1.80031f
C764 VDD.n10 VSS 0.27255f
C765 VDD.t106 VSS 0.51437f
C766 VDD.n11 VSS 0.09645f
C767 VDD.n12 VSS 0.10083f
C768 VDD.n13 VSS 0.10279f
C769 VDD.n14 VSS 0.10083f
C770 VDD.n15 VSS 0.09645f
C771 VDD.t94 VSS 0.64297f
C772 VDD.n16 VSS 0.09645f
C773 VDD.n17 VSS 0.10083f
C774 VDD.n18 VSS 0.10279f
C775 VDD.n19 VSS 0.10083f
C776 VDD.n20 VSS 0.09645f
C777 VDD.t58 VSS 0.90016f
C778 VDD.n21 VSS 0.43773f
C779 VDD.n22 VSS 5.70727f
C780 VDD.n23 VSS 0.09645f
C781 VDD.n24 VSS 0.10083f
C782 VDD.n25 VSS 0.08628f
C783 VDD.n26 VSS 0.10083f
C784 VDD.n27 VSS 0.09645f
C785 VDD.n28 VSS 4.92212f
C786 VDD.n29 VSS 3.71018f
C787 VDD.n30 VSS 4.50078f
C788 VDD.t112 VSS 2.57187f
C789 VDD.t116 VSS 0.51437f
C790 VDD.t120 VSS 0.64297f
C791 VDD.n31 VSS 3.60062f
C792 VDD.n32 VSS 0.09645f
C793 VDD.n33 VSS 0.10083f
C794 VDD.n34 VSS 0.27827f
C795 VDD.n35 VSS 0.10279f
C796 VDD.n36 VSS 0.10279f
C797 VDD.n37 VSS 0.10083f
C798 VDD.n38 VSS 0.09645f
C799 VDD.n39 VSS 4.75797f
C800 VDD.t82 VSS 1.80031f
C801 VDD.t90 VSS 0.51437f
C802 VDD.t2 VSS 0.51437f
C803 VDD.t72 VSS 1.15734f
C804 VDD.n40 VSS 1.02875f
C805 VDD.t16 VSS 0.38578f
C806 VDD.t14 VSS 0.51437f
C807 VDD.t68 VSS 0.51437f
C808 VDD.t64 VSS 0.51437f
C809 VDD.t66 VSS 0.38578f
C810 VDD.t98 VSS 0.25719f
C811 VDD.t6 VSS 0.25719f
C812 VDD.t78 VSS 0.25719f
C813 VDD.t60 VSS 0.25719f
C814 VDD.t70 VSS 0.25719f
C815 VDD.t8 VSS 0.25719f
C816 VDD.t104 VSS 0.25719f
C817 VDD.t62 VSS 0.25719f
C818 VDD.n41 VSS 0.43493f
C819 VDD.n42 VSS 0.27255f
C820 VDD.n43 VSS 0.27255f
C821 VDD.n44 VSS 2.23524f
C822 VDD.t52 VSS 1.80031f
C823 VDD.t54 VSS 0.51437f
C824 VDD.t56 VSS 0.51437f
C825 VDD.t20 VSS 0.51437f
C826 VDD.n45 VSS 2.44328f
C827 VDD.t102 VSS 2.44328f
C828 VDD.t118 VSS 0.51437f
C829 VDD.t122 VSS 0.51437f
C830 VDD.t4 VSS 0.51437f
C831 VDD.n46 VSS 1.02875f
C832 VDD.n47 VSS 0.09645f
C833 VDD.n48 VSS 0.10083f
C834 VDD.n49 VSS 0.10279f
C835 VDD.n50 VSS 0.10279f
C836 VDD.n51 VSS 0.10279f
C837 VDD.n52 VSS 0.10083f
C838 VDD.n53 VSS 0.09645f
C839 VDD.n54 VSS 0.25719f
C840 VDD.t128 VSS 2.31469f
C841 VDD.t51 VSS 2.44328f
C842 VDD.t50 VSS 0.51437f
C843 VDD.t49 VSS 0.51437f
C844 VDD.t48 VSS 0.38578f
C845 VDD.n55 VSS 0.25719f
C846 VDD.t47 VSS 0.38578f
C847 VDD.t46 VSS 0.51437f
C848 VDD.t45 VSS 0.51437f
C849 VDD.t44 VSS 2.44328f
C850 VDD.t76 VSS 2.31469f
C851 VDD.t84 VSS 0.51437f
C852 VDD.t74 VSS 0.51437f
C853 VDD.t108 VSS 2.44328f
C854 VDD.n56 VSS 2.44328f
C855 VDD.t36 VSS 0.51437f
C856 VDD.t38 VSS 0.51437f
C857 VDD.t40 VSS 0.51437f
C858 VDD.t42 VSS 1.80031f
C859 VDD.n57 VSS 2.23524f
C860 VDD.t86 VSS 0.64297f
C861 VDD.n58 VSS 0.25719f
C862 VDD.n59 VSS 0.09645f
C863 VDD.n60 VSS 0.10083f
C864 VDD.n61 VSS 0.10279f
C865 VDD.n62 VSS 0.10279f
C866 VDD.n63 VSS 0.10279f
C867 VDD.n64 VSS 0.10083f
C868 VDD.n65 VSS 0.09645f
C869 VDD.n66 VSS 1.02875f
C870 VDD.t34 VSS 0.90016f
C871 VDD.t126 VSS 0.25719f
C872 VDD.t32 VSS 0.25719f
C873 VDD.t96 VSS 0.25719f
C874 VDD.t30 VSS 0.25719f
C875 VDD.t130 VSS 0.25719f
C876 VDD.t28 VSS 0.25719f
C877 VDD.t92 VSS 0.25719f
C878 VDD.t26 VSS 0.25719f
C879 VDD.t114 VSS 0.51437f
C880 VDD.t124 VSS 0.51437f
C881 VDD.t110 VSS 1.15734f
C882 VDD.n67 VSS 1.02875f
C883 VDD.t12 VSS 0.38578f
C884 VDD.t10 VSS 0.51437f
C885 VDD.t18 VSS 0.51437f
C886 VDD.t22 VSS 0.51437f
C887 VDD.t24 VSS 0.38578f
C888 VDD.n68 VSS 0.43493f
C889 VDD.n69 VSS 0.27255f
C890 VDD.n70 VSS 0.27255f
C891 VDD.t88 VSS 0.51437f
C892 VDD.t80 VSS 2.57187f
C893 VDD.n71 VSS 5.70727f
C894 VDD.n72 VSS 4.75797f
C895 VDD.n73 VSS 0.09645f
C896 VDD.n74 VSS 0.10083f
C897 VDD.n75 VSS 0.10279f
C898 VDD.n76 VSS 0.10279f
C899 VDD.n77 VSS 0.10279f
C900 VDD.n78 VSS 0.10083f
C901 VDD.n79 VSS 0.09645f
C902 VDD.n80 VSS 3.60062f
C903 VDD.n81 VSS 4.50078f
C904 VDD.n82 VSS 3.69744f
C905 VDD.n83 VSS 4.91605f
C906 VDD.n84 VSS 0.0819f
C907 VDD.n85 VSS 0.10717f
C908 VDD.n86 VSS 0.15431f
C909 VDD.t127 VSS 0.18477f
C910 VDD.t97 VSS 0.18477f
C911 VDD.n87 VSS 0.05769f
C912 VDD.t131 VSS 0.18477f
C913 VDD.t93 VSS 0.1881f
C914 VDD.n88 VSS 0.05814f
C915 VDD.n89 VSS 0.15388f
C916 VDD.n90 VSS 0.2294f
C917 VDD.n91 VSS 0.15431f
C918 VDD.t95 VSS 0.1881f
C919 VDD.t129 VSS 0.18807f
C920 VDD.n92 VSS 0.12736f
C921 VDD.n93 VSS 0.17294f
C922 VDD.n94 VSS 0.15431f
C923 VDD.t105 VSS 0.18946f
C924 VDD.t71 VSS 0.1861f
C925 VDD.n95 VSS 0.05792f
C926 VDD.t79 VSS 0.1861f
C927 VDD.t99 VSS 0.1861f
C928 VDD.n96 VSS 0.05781f
C929 VDD.n97 VSS 0.15398f
C930 VDD.n98 VSS 0.20954f
C931 VDD.t117 VSS 0.13447f
C932 VDD.t113 VSS 0.13683f
C933 VDD.n99 VSS 0.05814f
C934 VDD.t121 VSS 0.1939f
C935 VDD.n100 VSS 0.16993f
C936 VDD.n101 VSS 0.71628f
C937 VDD.t83 VSS 0.1276f
C938 VDD.t91 VSS 0.1276f
C939 VDD.n102 VSS 0.05769f
C940 VDD.t3 VSS 0.1276f
C941 VDD.t73 VSS 0.12984f
C942 VDD.n103 VSS 0.05814f
C943 VDD.n104 VSS 0.15388f
C944 VDD.n105 VSS 0.26754f
C945 VDD.t7 VSS 0.1061f
C946 VDD.t59 VSS 0.10869f
C947 VDD.n106 VSS 0.05814f
C948 VDD.t9 VSS 0.1061f
C949 VDD.t61 VSS 0.1061f
C950 VDD.n107 VSS 0.05769f
C951 VDD.n108 VSS 0.02923f
C952 VDD.t67 VSS 0.1061f
C953 VDD.t63 VSS 0.1061f
C954 VDD.n109 VSS 0.05769f
C955 VDD.n110 VSS 0.01655f
C956 VDD.t69 VSS 0.1061f
C957 VDD.t65 VSS 0.1061f
C958 VDD.n111 VSS 0.05769f
C959 VDD.n112 VSS 0.01655f
C960 VDD.t17 VSS 0.1061f
C961 VDD.t15 VSS 0.1061f
C962 VDD.n113 VSS 0.05769f
C963 VDD.n114 VSS 0.23728f
C964 VDD.n115 VSS 0.17835f
C965 VDD.n116 VSS 0.09208f
C966 VDD.n117 VSS 0.51877f
C967 VDD.n118 VSS 0.15431f
C968 VDD.n119 VSS 0.02572f
C969 VDD.t119 VSS 0.18477f
C970 VDD.t103 VSS 0.1881f
C971 VDD.n120 VSS 0.05814f
C972 VDD.t5 VSS 0.18477f
C973 VDD.t123 VSS 0.18477f
C974 VDD.n121 VSS 0.05769f
C975 VDD.n122 VSS 0.10225f
C976 VDD.n123 VSS 0.14669f
C977 VDD.n124 VSS 0.07073f
C978 VDD.t21 VSS 0.1413f
C979 VDD.t57 VSS 0.1413f
C980 VDD.n125 VSS 0.05769f
C981 VDD.t55 VSS 0.1413f
C982 VDD.t53 VSS 0.1438f
C983 VDD.n126 VSS 0.05814f
C984 VDD.n127 VSS 0.1243f
C985 VDD.n128 VSS 0.17565f
C986 VDD.n129 VSS 0.07073f
C987 VDD.n130 VSS 0.15431f
C988 VDD.n131 VSS 0.15431f
C989 VDD.n132 VSS 0.10287f
C990 VDD.t77 VSS 0.18942f
C991 VDD.t87 VSS 0.18946f
C992 VDD.n133 VSS 0.12513f
C993 VDD.n134 VSS 0.17192f
C994 VDD.n135 VSS 0.05787f
C995 VDD.t43 VSS 0.1413f
C996 VDD.t41 VSS 0.1413f
C997 VDD.n136 VSS 0.05769f
C998 VDD.t39 VSS 0.1413f
C999 VDD.t37 VSS 0.1438f
C1000 VDD.n137 VSS 0.05814f
C1001 VDD.n138 VSS 0.1243f
C1002 VDD.n139 VSS 0.1705f
C1003 VDD.t109 VSS 0.1861f
C1004 VDD.t75 VSS 0.1861f
C1005 VDD.n140 VSS 0.05769f
C1006 VDD.t85 VSS 0.1861f
C1007 VDD.t107 VSS 0.18946f
C1008 VDD.n141 VSS 0.05814f
C1009 VDD.n142 VSS 0.09473f
C1010 VDD.n143 VSS 0.13835f
C1011 VDD.t11 VSS 0.1061f
C1012 VDD.t13 VSS 0.1061f
C1013 VDD.n144 VSS 0.05814f
C1014 VDD.t23 VSS 0.1061f
C1015 VDD.t19 VSS 0.1061f
C1016 VDD.n145 VSS 0.05769f
C1017 VDD.n146 VSS 0.02923f
C1018 VDD.t27 VSS 0.1061f
C1019 VDD.t25 VSS 0.1061f
C1020 VDD.n147 VSS 0.05769f
C1021 VDD.n148 VSS 0.01655f
C1022 VDD.t31 VSS 0.1061f
C1023 VDD.t29 VSS 0.1061f
C1024 VDD.n149 VSS 0.05769f
C1025 VDD.n150 VSS 0.01655f
C1026 VDD.t35 VSS 0.10869f
C1027 VDD.t33 VSS 0.1061f
C1028 VDD.n151 VSS 0.05769f
C1029 VDD.n152 VSS 0.22501f
C1030 VDD.n153 VSS 0.1625f
C1031 VDD.n154 VSS 0.05191f
C1032 VDD.n155 VSS 0.15431f
C1033 VDD.n156 VSS 0.15431f
C1034 VDD.n157 VSS 0.0643f
C1035 VDD.t111 VSS 0.13683f
C1036 VDD.t125 VSS 0.13447f
C1037 VDD.n158 VSS 0.05769f
C1038 VDD.t115 VSS 0.13447f
C1039 VDD.t101 VSS 0.13447f
C1040 VDD.n159 VSS 0.05814f
C1041 VDD.n160 VSS 0.15388f
C1042 VDD.n161 VSS 0.20522f
C1043 VDD.n162 VSS 0.13374f
C1044 VDD.t89 VSS 0.1276f
C1045 VDD.t1 VSS 0.12984f
C1046 VDD.n163 VSS 0.05814f
C1047 VDD.t81 VSS 0.18704f
C1048 VDD.n164 VSS 0.16081f
C1049 VDD.n165 VSS 0.20572f
C1050 VDD.n166 VSS 0.0913f
C1051 VDD.n167 VSS 0.15431f
C1052 VDD.n168 VSS 0.14788f
C1053 VDD.n169 VSS 0.10612f
C1054 VDD.n170 VSS 0.03004f
C1055 SENSE_CLK.n0 VSS 0.48365f
C1056 SENSE_CLK.n1 VSS 0.08696f
C1057 SENSE_CLK.n2 VSS 0.1341f
C1058 SENSE_CLK.n3 VSS 0.18794f
C1059 SENSE_CLK.n4 VSS 0.1341f
C1060 SENSE_CLK.n5 VSS 0.08696f
C1061 SENSE_CLK.n6 VSS 0.08696f
C1062 SENSE_CLK.n7 VSS 0.1341f
C1063 SENSE_CLK.n8 VSS 0.37129f
C1064 SENSE_CLK.n9 VSS 0.1341f
C1065 SENSE_CLK.n10 VSS 0.1251f
C1066 SENSE_CLK.n11 VSS 0.2531f
C1067 SENSE_CLK.n12 VSS 0.1341f
C1068 SENSE_CLK.n13 VSS 0.18794f
C1069 SENSE_CLK.n14 VSS 0.18794f
C1070 SENSE_CLK.n15 VSS 0.18794f
C1071 SENSE_CLK.n16 VSS 0.1341f
C1072 SENSE_CLK.n17 VSS 0.08696f
C1073 SENSE_CLK.n18 VSS 0.08696f
C1074 SENSE_CLK.n19 VSS 0.08696f
C1075 SENSE_CLK.n20 VSS 0.1341f
C1076 SENSE_CLK.n21 VSS 0.18794f
C1077 SENSE_CLK.n22 VSS 0.18794f
C1078 SENSE_CLK.n23 VSS 0.18794f
C1079 SENSE_CLK.n24 VSS 0.1341f
C1080 SENSE_CLK.n25 VSS 0.12674f
C1081 SENSE_CLK.n26 VSS 0.32414f
C1082 SENSE_CLK.n27 VSS 3.60178f
C1083 SENSE_CLK.n28 VSS 0.12682f
C1084 SENSE_CLK.n29 VSS 0.1251f
C1085 SENSE_CLK.n30 VSS 0.1341f
C1086 SENSE_CLK.n31 VSS 0.1341f
C1087 SENSE_CLK.n32 VSS 0.24536f
C1088 SENSE_CLK.n33 VSS 1.71715f
C1089 SENSE_CLK.n34 VSS 5.34728f
C1090 SENSE_CLK.n35 VSS 0.46428f
C1091 SENSE_CLK.n36 VSS 0.12223f
C1092 SENSE_CLK.n37 VSS 0.08696f
C1093 SENSE_CLK.n38 VSS 0.1341f
C1094 SENSE_CLK.n39 VSS 0.08696f
C1095 SENSE_CLK.n40 VSS 0.1341f
C1096 SENSE_CLK.n41 VSS 0.18774f
C1097 SENSE_CLK.n42 VSS 0.18794f
C1098 SENSE_CLK.n43 VSS 0.18794f
C1099 SENSE_CLK.n44 VSS 0.18794f
C1100 SENSE_CLK.n45 VSS 0.37129f
C1101 SENSE_CLK.n46 VSS 0.1251f
C1102 SENSE_CLK.n47 VSS 0.2531f
C1103 SENSE_CLK.n48 VSS 0.1341f
C1104 SENSE_CLK.n49 VSS 0.1341f
C1105 SENSE_CLK.n50 VSS 0.1341f
C1106 SENSE_CLK.n51 VSS 0.1341f
C1107 SENSE_CLK.n52 VSS 0.08676f
C1108 SENSE_CLK.n53 VSS 0.2027f
C1109 SENSE_CLK.n54 VSS 3.0982f
C1110 SENSE_CLK.n55 VSS 2.12295f
C1111 SENSE_CLK.n56 VSS 0.06802f
C1112 SENSE_CLK.n57 VSS 0.15472f
C1113 SENSE_CLK.n58 VSS 0.146f
C1114 SENSE_CLK.n59 VSS 0.25214f
C1115 SENSE_CLK.n60 VSS 0.15472f
C1116 SENSE_CLK.n61 VSS 0.15472f
C1117 SENSE_CLK.n62 VSS 0.14767f
C1118 SENSE_CLK.n63 VSS 0.28811f
C1119 SENSE_CLK.n64 VSS 0.93041f
C1120 SENSE_CLK.n65 VSS 0.12682f
C1121 SENSE_CLK.n66 VSS 0.1251f
C1122 SENSE_CLK.n67 VSS 0.1341f
C1123 SENSE_CLK.n68 VSS 0.1341f
C1124 SENSE_CLK.n69 VSS 0.24536f
C1125 SENSE_CLK.n70 VSS 1.71715f
C1126 SENSE_CLK.n71 VSS 3.58675f
C1127 SENSE_CLK.n72 VSS 0.39921f
C1128 SENSE_CLK.n73 VSS 0.08696f
C1129 SENSE_CLK.n74 VSS 0.08696f
C1130 SENSE_CLK.n75 VSS 0.08696f
C1131 SENSE_CLK.n76 VSS 0.08696f
C1132 SENSE_CLK.n77 VSS 0.08696f
C1133 SENSE_CLK.n78 VSS 0.08696f
C1134 SENSE_CLK.n79 VSS 0.2531f
C1135 SENSE_CLK.n80 VSS 0.18794f
C1136 SENSE_CLK.n81 VSS 0.18794f
C1137 SENSE_CLK.n82 VSS 0.18794f
C1138 SENSE_CLK.n83 VSS 0.18794f
C1139 SENSE_CLK.n84 VSS 0.18794f
C1140 SENSE_CLK.n85 VSS 0.18794f
C1141 SENSE_CLK.n86 VSS 0.18794f
C1142 SENSE_CLK.n87 VSS 0.37129f
C1143 SENSE_CLK.n88 VSS 0.1251f
C1144 SENSE_CLK.n89 VSS 0.1341f
C1145 SENSE_CLK.n90 VSS 0.1341f
C1146 SENSE_CLK.n91 VSS 0.1341f
C1147 SENSE_CLK.n92 VSS 0.1341f
C1148 SENSE_CLK.n93 VSS 0.1341f
C1149 SENSE_CLK.n94 VSS 0.1341f
C1150 SENSE_CLK.n95 VSS 0.1341f
C1151 SENSE_CLK.n96 VSS 0.1341f
C1152 SENSE_CLK.n97 VSS 0.12674f
C1153 SENSE_CLK.n98 VSS 0.23953f
C1154 SENSE_CLK.n99 VSS 3.10441f
C1155 SENSE_CLK.n100 VSS 4.36938f
C1156 OUTP.t3 VSS 0.22567f
C1157 OUTP.t4 VSS 0.22567f
C1158 OUTP.n0 VSS 0.56561f
C1159 OUTP.t0 VSS 0.81451f
C1160 OUTP.n1 VSS 0.52821f
C1161 OUTP.t5 VSS 0.81401f
C1162 OUTP.t6 VSS 0.22567f
C1163 OUTP.t1 VSS 0.22567f
C1164 OUTP.n2 VSS 0.56112f
C1165 OUTP.n3 VSS 0.28431f
C1166 OUTP.t2 VSS 0.80874f
C1167 OUTP.n4 VSS 0.38673f
C1168 OUTP.n5 VSS 1.28652f
C1169 OUTN.t4 VSS 0.84494f
C1170 OUTN.t6 VSS 0.23629f
C1171 OUTN.t1 VSS 0.23629f
C1172 OUTN.n0 VSS 0.58043f
C1173 OUTN.n1 VSS 0.2941f
C1174 OUTN.t0 VSS 0.83944f
C1175 OUTN.n2 VSS 0.44015f
C1176 OUTN.t5 VSS 0.23629f
C1177 OUTN.t3 VSS 0.23629f
C1178 OUTN.n3 VSS 0.58508f
C1179 OUTN.t2 VSS 0.84546f
C1180 OUTN.n4 VSS 0.50614f
C1181 OUTN.n5 VSS 1.34972f
C1182 INP.n0 VSS 0.18412f
C1183 INP.n1 VSS 0.16565f
C1184 INP.n2 VSS 0.08783f
C1185 INP.n3 VSS 0.08194f
C1186 INP.n4 VSS 0.24318f
C1187 INP.n5 VSS 0.12297f
C1188 INP.n6 VSS 0.08783f
C1189 INP.n7 VSS 0.08783f
C1190 INP.n8 VSS 0.05696f
C1191 INP.n9 VSS 0.08783f
C1192 INP.n10 VSS 0.12309f
C1193 INP.n11 VSS 0.05696f
C1194 INP.n12 VSS 0.05696f
C1195 INP.n13 VSS 0.05696f
C1196 INP.n14 VSS 0.16578f
C1197 INP.n15 VSS 0.12309f
C1198 INP.n16 VSS 0.12309f
C1199 INP.n17 VSS 0.24318f
C1200 INP.n18 VSS 0.08194f
C1201 INP.n19 VSS 0.08783f
C1202 INP.n20 VSS 0.08783f
C1203 INP.n21 VSS 0.08783f
C1204 INP.n22 VSS 0.08783f
C1205 INP.n23 VSS 0.08783f
C1206 INP.n24 VSS 0.12309f
C1207 INP.n25 VSS 0.12309f
C1208 INP.n26 VSS 0.12297f
C1209 INP.n27 VSS 0.08783f
C1210 INP.n28 VSS 0.05683f
C1211 INP.n29 VSS 0.07914f
C1212 INP.n30 VSS 2.90389f
C1213 INN.n0 VSS 0.26747f
C1214 INN.n1 VSS 0.08255f
C1215 INN.n2 VSS 0.1276f
C1216 INN.n3 VSS 0.17882f
C1217 INN.n4 VSS 0.08274f
C1218 INN.n5 VSS 0.08274f
C1219 INN.n6 VSS 0.08274f
C1220 INN.n7 VSS 0.08274f
C1221 INN.n8 VSS 0.24083f
C1222 INN.n9 VSS 0.17882f
C1223 INN.n10 VSS 0.17882f
C1224 INN.n11 VSS 0.35328f
C1225 INN.n12 VSS 0.11904f
C1226 INN.n13 VSS 0.1276f
C1227 INN.n14 VSS 0.1276f
C1228 INN.n15 VSS 0.1276f
C1229 INN.n16 VSS 0.1276f
C1230 INN.n17 VSS 0.1276f
C1231 INN.n18 VSS 0.17882f
C1232 INN.n19 VSS 0.17882f
C1233 INN.n20 VSS 0.17864f
C1234 INN.n21 VSS 0.1276f
C1235 INN.n22 VSS 0.1276f
C1236 INN.n23 VSS 0.11904f
C1237 INN.n24 VSS 0.1276f
C1238 INN.n25 VSS 0.35328f
C1239 INN.n26 VSS 0.17864f
C1240 INN.n27 VSS 0.1276f
C1241 INN.n28 VSS 0.24064f
C1242 INN.n29 VSS 0.11497f
C1243 INN.n30 VSS 4.47345f
C1244 SENSE_BOOST_CLK.n0 VSS 0.12585f
C1245 SENSE_BOOST_CLK.n1 VSS 0.04212f
C1246 SENSE_BOOST_CLK.n2 VSS 0.07511f
C1247 SENSE_BOOST_CLK.n3 VSS 0.10146f
C1248 SENSE_BOOST_CLK.n4 VSS 0.04222f
C1249 SENSE_BOOST_CLK.n5 VSS 0.04222f
C1250 SENSE_BOOST_CLK.n6 VSS 0.04222f
C1251 SENSE_BOOST_CLK.n7 VSS 0.04222f
C1252 SENSE_BOOST_CLK.n8 VSS 0.04222f
C1253 SENSE_BOOST_CLK.n9 VSS 0.04222f
C1254 SENSE_BOOST_CLK.n10 VSS 0.04222f
C1255 SENSE_BOOST_CLK.n11 VSS 0.04222f
C1256 SENSE_BOOST_CLK.n12 VSS 0.04222f
C1257 SENSE_BOOST_CLK.n13 VSS 0.04222f
C1258 SENSE_BOOST_CLK.n14 VSS 0.12288f
C1259 SENSE_BOOST_CLK.n15 VSS 0.10146f
C1260 SENSE_BOOST_CLK.n16 VSS 0.10146f
C1261 SENSE_BOOST_CLK.n17 VSS 0.10146f
C1262 SENSE_BOOST_CLK.n18 VSS 0.10146f
C1263 SENSE_BOOST_CLK.n19 VSS 0.10146f
C1264 SENSE_BOOST_CLK.n20 VSS 0.10146f
C1265 SENSE_BOOST_CLK.n21 VSS 0.10146f
C1266 SENSE_BOOST_CLK.n22 VSS 0.10146f
C1267 SENSE_BOOST_CLK.n23 VSS 0.20071f
C1268 SENSE_BOOST_CLK.n24 VSS 0.07088f
C1269 SENSE_BOOST_CLK.n25 VSS 0.07511f
C1270 SENSE_BOOST_CLK.n26 VSS 0.07511f
C1271 SENSE_BOOST_CLK.n27 VSS 0.07511f
C1272 SENSE_BOOST_CLK.n28 VSS 0.07511f
C1273 SENSE_BOOST_CLK.n29 VSS 0.07511f
C1274 SENSE_BOOST_CLK.n30 VSS 0.07511f
C1275 SENSE_BOOST_CLK.n31 VSS 0.07511f
C1276 SENSE_BOOST_CLK.n32 VSS 0.07511f
C1277 SENSE_BOOST_CLK.n33 VSS 0.07511f
C1278 SENSE_BOOST_CLK.n34 VSS 0.07511f
C1279 SENSE_BOOST_CLK.n35 VSS 0.07511f
C1280 SENSE_BOOST_CLK.n36 VSS 0.10146f
C1281 SENSE_BOOST_CLK.n37 VSS 0.10146f
C1282 SENSE_BOOST_CLK.n38 VSS 0.10137f
C1283 SENSE_BOOST_CLK.n39 VSS 0.07511f
C1284 SENSE_BOOST_CLK.n40 VSS 0.07511f
C1285 SENSE_BOOST_CLK.n41 VSS 0.04222f
C1286 SENSE_BOOST_CLK.n42 VSS 0.07511f
C1287 SENSE_BOOST_CLK.n43 VSS 0.10146f
C1288 SENSE_BOOST_CLK.n44 VSS 0.04222f
C1289 SENSE_BOOST_CLK.n45 VSS 0.04222f
C1290 SENSE_BOOST_CLK.n46 VSS 0.04222f
C1291 SENSE_BOOST_CLK.n47 VSS 0.04222f
C1292 SENSE_BOOST_CLK.n48 VSS 0.12288f
C1293 SENSE_BOOST_CLK.n49 VSS 0.10146f
C1294 SENSE_BOOST_CLK.n50 VSS 0.10146f
C1295 SENSE_BOOST_CLK.n51 VSS 0.10146f
C1296 SENSE_BOOST_CLK.n52 VSS 0.20071f
C1297 SENSE_BOOST_CLK.n53 VSS 0.07088f
C1298 SENSE_BOOST_CLK.n54 VSS 0.07511f
C1299 SENSE_BOOST_CLK.n55 VSS 0.07511f
C1300 SENSE_BOOST_CLK.n56 VSS 0.07511f
C1301 SENSE_BOOST_CLK.n57 VSS 0.07511f
C1302 SENSE_BOOST_CLK.n58 VSS 0.07511f
C1303 SENSE_BOOST_CLK.n59 VSS 0.07511f
C1304 SENSE_BOOST_CLK.n60 VSS 0.10146f
C1305 SENSE_BOOST_CLK.n61 VSS 0.10146f
C1306 SENSE_BOOST_CLK.n62 VSS 0.10137f
C1307 SENSE_BOOST_CLK.n63 VSS 0.07511f
C1308 SENSE_BOOST_CLK.n64 VSS 0.04212f
C1309 SENSE_BOOST_CLK.n65 VSS 0.07607f
C1310 SENSE_BOOST_CLK.n66 VSS 2.29248f
.ends
