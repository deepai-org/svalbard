* PEX produced using /foss/tools/sak/sak-pex.sh with m=3 and s=1 (extresist threshold=0 mOhm, minres=1 mOhm, mindelay=0 ps)
* NGSPICE file created from clock_level_converter_pex.ext - technology: gf180mcuD

.subckt clock_level_converter_pex INP INN VBIAS VDD VSS OUTP OUTN
X0 a_n3720_9000.t3 a_n3720_9000.t2 VDD.t47 VDD.t46 pfet_03v3 ad=1.76p pd=8.88u as=1.04p ps=4.52u w=4u l=0.28u
X1 a_n9244_3330.t5 INP.t2 a_n3652_n800.t7 VSS.t53 nfet_03v3 ad=3.52p pd=16.88u as=2.08p ps=8.52u w=8u l=0.28u
X2 VSS.t30 VBIAS.t7 a_n3652_n800.t0 VSS.t29 nfet_03v3 ad=2.6p pd=10.52u as=4.4p ps=20.88u w=10u l=0.28u
X3 OUTP.t1 a_n7716_3200.t4 VDD.t3 VDD.t2 pfet_03v3 ad=5.28p pd=24.88u as=3.12p ps=12.52u w=12u l=0.28u
X4 VDD.t35 a_1004_n800.t0 a_1004_n800.t1 VDD.t34 pfet_03v3 ad=1.04p pd=4.52u as=1.76p ps=8.88u w=4u l=0.28u
X5 VSS.t1 a_n9316_3400.t2 a_n7716_3200.t0 VSS.t0 nfet_03v3 ad=1.76p pd=8.88u as=1.76p ps=8.88u w=4u l=0.28u
X6 a_1148_n800.t5 INN.t1 a_n4444_1746.t4 VSS.t50 nfet_03v3 ad=2.08p pd=8.52u as=3.52p ps=16.88u w=8u l=0.28u
X7 VSS.t47 a_7556_3130.t2 a_5880_2800.t0 VSS.t46 nfet_03v3 ad=1.76p pd=8.88u as=1.76p ps=8.88u w=4u l=0.28u
X8 VDD.t27 a_n4444_1746.t8 a_n9244_3330.t1 VDD.t26 pfet_03v3 ad=1.32p pd=6.88u as=1.32p ps=6.88u w=3u l=0.28u
X9 VDD.t7 a_n9244_3330.t8 a_n4444_1746.t0 VDD.t6 pfet_03v3 ad=1.32p pd=6.88u as=1.32p ps=6.88u w=3u l=0.28u
X10 a_n3720_9000.t5 INN.t2 a_n3652_n800.t4 VSS.t49 nfet_03v3 ad=3.52p pd=16.88u as=2.08p ps=8.52u w=8u l=0.28u
X11 VSS.t23 a_n9244_3330.t7 a_n9316_3400.t0 VSS.t22 nfet_03v3 ad=0.88p pd=4.88u as=0.88p ps=4.88u w=2u l=0.28u
X12 a_1148_n800.t7 INP.t1 a_1004_n800.t4 VSS.t54 nfet_03v3 ad=2.08p pd=8.52u as=3.52p ps=16.88u w=8u l=0.28u
X13 VSS.t28 a_n4444_1746.t7 a_7556_3130.t0 VSS.t27 nfet_03v3 ad=0.88p pd=4.88u as=0.88p ps=4.88u w=2u l=0.28u
X14 VDD.t25 a_5880_2800.t5 OUTN.t1 VDD.t18 pfet_03v3 ad=3.12p pd=12.52u as=5.28p ps=24.88u w=12u l=0.28u
X15 VDD.t5 a_n9316_3400.t3 a_n7716_3200.t1 VDD.t4 pfet_03v3 ad=3.52p pd=16.88u as=3.52p ps=16.88u w=8u l=0.28u
X16 OUTP.t0 a_n7716_3200.t2 VSS.t3 VSS.t2 nfet_03v3 ad=2.64p pd=12.88u as=1.56p ps=6.52u w=6u l=0.28u
X17 VSS.t40 VBIAS.t3 a_1148_n800.t0 VSS.t39 nfet_03v3 ad=2.6p pd=10.52u as=4.4p ps=20.88u w=10u l=0.28u
X18 VSS.t45 a_n7716_3200.t3 OUTP.t3 VSS.t5 nfet_03v3 ad=1.56p pd=6.52u as=2.64p ps=12.88u w=6u l=0.28u
X19 VSS.t19 a_5880_2800.t3 OUTN.t0 VSS.t12 nfet_03v3 ad=1.56p pd=6.52u as=2.64p ps=12.88u w=6u l=0.28u
X20 a_n3652_n800.t1 VBIAS.t6 VSS.t32 VSS.t31 nfet_03v3 ad=2.6p pd=10.52u as=2.6p ps=10.52u w=10u l=0.28u
X21 a_1148_n800.t3 VBIAS.t0 VSS.t44 VSS.t43 nfet_03v3 ad=4.4p pd=20.88u as=2.6p ps=10.52u w=10u l=0.28u
X22 VDD.t33 a_n3720_9000.t7 a_n9244_3330.t2 VDD.t32 pfet_03v3 ad=1.04p pd=4.52u as=1.76p ps=8.88u w=4u l=0.28u
X23 a_n4444_1746.t3 a_1004_n800.t6 VDD.t43 VDD.t42 pfet_03v3 ad=1.76p pd=8.88u as=1.04p ps=4.52u w=4u l=0.28u
X24 OUTN.t2 a_5880_2800.t2 VSS.t24 VSS.t16 nfet_03v3 ad=2.64p pd=12.88u as=1.56p ps=6.52u w=6u l=0.28u
X25 VDD.t9 a_n9244_3330.t9 a_n9316_3400.t1 VDD.t8 pfet_03v3 ad=1.76p pd=8.88u as=1.76p ps=8.88u w=4u l=0.28u
X26 VDD.t16 VDD.t14 VDD.t15 VDD.t2 pfet_03v3 ad=1.04p pd=4.52u as=0 ps=0 w=4u l=0.28u
X27 VSS.t26 a_n4444_1746.t6 a_n9244_3330.t0 VSS.t25 nfet_03v3 ad=0.44p pd=2.88u as=0.44p ps=2.88u w=1u l=0.28u
X28 VDD.t37 a_n7716_3200.t5 OUTP.t2 VDD.t11 pfet_03v3 ad=3.12p pd=12.52u as=5.28p ps=24.88u w=12u l=0.28u
X29 VDD.t41 a_7556_3130.t3 a_5880_2800.t1 VDD.t40 pfet_03v3 ad=3.52p pd=16.88u as=3.52p ps=16.88u w=8u l=0.28u
X30 VDD.t31 a_n3720_9000.t0 a_n3720_9000.t1 VDD.t30 pfet_03v3 ad=1.04p pd=4.52u as=1.76p ps=8.88u w=4u l=0.28u
X31 VDD.t20 VDD.t17 VDD.t19 VDD.t18 pfet_03v3 ad=1.76p pd=8.88u as=0 ps=0 w=4u l=0.28u
X32 VSS.t21 a_n9244_3330.t6 a_n4444_1746.t1 VSS.t20 nfet_03v3 ad=0.44p pd=2.88u as=0.44p ps=2.88u w=1u l=0.28u
X33 a_n3652_n800.t6 INP.t3 a_n9244_3330.t4 VSS.t52 nfet_03v3 ad=2.08p pd=8.52u as=3.52p ps=16.88u w=8u l=0.28u
X34 VDD.t13 VDD.t10 VDD.t12 VDD.t11 pfet_03v3 ad=1.76p pd=8.88u as=0 ps=0 w=4u l=0.28u
X35 a_1004_n800.t3 a_1004_n800.t2 VDD.t1 VDD.t0 pfet_03v3 ad=1.76p pd=8.88u as=1.04p ps=4.52u w=4u l=0.28u
X36 a_n4444_1746.t5 INN.t0 a_1148_n800.t4 VSS.t51 nfet_03v3 ad=3.52p pd=16.88u as=2.08p ps=8.52u w=8u l=0.28u
X37 VSS.t38 VBIAS.t5 a_n3652_n800.t2 VSS.t37 nfet_03v3 ad=2.6p pd=10.52u as=2.6p ps=10.52u w=10u l=0.28u
X38 VSS.t34 VBIAS.t1 a_1148_n800.t2 VSS.t33 nfet_03v3 ad=2.6p pd=10.52u as=2.6p ps=10.52u w=10u l=0.28u
X39 VDD.t24 VDD.t21 VDD.t23 VDD.t22 pfet_03v3 ad=1.04p pd=4.52u as=0 ps=0 w=4u l=0.28u
X40 a_n9244_3330.t3 a_n3720_9000.t6 VDD.t45 VDD.t44 pfet_03v3 ad=1.76p pd=8.88u as=1.04p ps=4.52u w=4u l=0.28u
X41 VSS.t10 VSS.t8 VSS.t9 VSS.t2 nfet_03v3 ad=2.08p pd=8.52u as=0 ps=0 w=8u l=0.28u
X42 VDD.t29 a_n4444_1746.t9 a_7556_3130.t1 VDD.t28 pfet_03v3 ad=1.76p pd=8.88u as=1.76p ps=8.88u w=4u l=0.28u
X43 VDD.t39 a_1004_n800.t7 a_n4444_1746.t2 VDD.t38 pfet_03v3 ad=1.04p pd=4.52u as=1.76p ps=8.88u w=4u l=0.28u
X44 a_n3652_n800.t5 INN.t3 a_n3720_9000.t4 VSS.t48 nfet_03v3 ad=2.08p pd=8.52u as=3.52p ps=16.88u w=8u l=0.28u
X45 VSS.t14 VSS.t11 VSS.t13 VSS.t12 nfet_03v3 ad=3.52p pd=16.88u as=0 ps=0 w=8u l=0.28u
X46 VSS.t7 VSS.t4 VSS.t6 VSS.t5 nfet_03v3 ad=3.52p pd=16.88u as=0 ps=0 w=8u l=0.28u
X47 a_1004_n800.t5 INP.t0 a_1148_n800.t6 VSS.t55 nfet_03v3 ad=3.52p pd=16.88u as=2.08p ps=8.52u w=8u l=0.28u
X48 OUTN.t3 a_5880_2800.t4 VDD.t36 VDD.t22 pfet_03v3 ad=5.28p pd=24.88u as=3.12p ps=12.52u w=12u l=0.28u
X49 VSS.t18 VSS.t15 VSS.t17 VSS.t16 nfet_03v3 ad=2.08p pd=8.52u as=0 ps=0 w=8u l=0.28u
X50 a_n3652_n800.t3 VBIAS.t4 VSS.t42 VSS.t41 nfet_03v3 ad=4.4p pd=20.88u as=2.6p ps=10.52u w=10u l=0.28u
X51 a_1148_n800.t1 VBIAS.t2 VSS.t36 VSS.t35 nfet_03v3 ad=2.6p pd=10.52u as=2.6p ps=10.52u w=10u l=0.28u
R0 VBIAS.n1 VBIAS.t0 139.702
R1 VBIAS.n7 VBIAS.t4 139.702
R2 VBIAS.n3 VBIAS.t2 135.246
R3 VBIAS.n4 VBIAS.t3 135.246
R4 VBIAS.n2 VBIAS.t1 135.246
R5 VBIAS.n8 VBIAS.t5 135.246
R6 VBIAS.n9 VBIAS.t6 135.246
R7 VBIAS.n10 VBIAS.t7 135.246
R8 VBIAS.n12 VBIAS.n5 18.7048
R9 VBIAS.n5 VBIAS.n4 18.5179
R10 VBIAS.n11 VBIAS.n10 18.5179
R11 VBIAS.n3 VBIAS.n0 18.4942
R12 VBIAS.n9 VBIAS.n6 18.4942
R13 VBIAS.n12 VBIAS.n11 14.0679
R14 VBIAS VBIAS.n12 12.8748
R15 VBIAS.n3 VBIAS.n2 11.6805
R16 VBIAS.n4 VBIAS.n3 11.6805
R17 VBIAS.n9 VBIAS.n8 11.6805
R18 VBIAS.n10 VBIAS.n9 11.6805
R19 VBIAS.n1 VBIAS.n0 7.17687
R20 VBIAS.n7 VBIAS.n6 7.17687
R21 VBIAS.n2 VBIAS.n1 4.42851
R22 VBIAS.n8 VBIAS.n7 4.42851
R23 VBIAS.n5 VBIAS.n0 0.0785
R24 VBIAS.n11 VBIAS.n6 0.0785
R25 INN.n1 INN.t3 113.632
R26 INN.n0 INN.t1 113.632
R27 INN.n1 INN.t2 113.603
R28 INN.n0 INN.t0 113.603
R29 INN.n2 INN.n0 28.8849
R30 INN.n2 INN.n1 24.2479
R31 INN INN.n2 15.027
R32 INP.n1 INP.t3 113.632
R33 INP.n0 INP.t1 113.632
R34 INP.n1 INP.t2 113.603
R35 INP.n0 INP.t0 113.603
R36 INP.n2 INP.n0 29.1979
R37 INP.n2 INP.n1 24.561
R38 INP INP.n2 13.0705
R39 OUTN OUTN.n2 14.8314
R40 OUTN.n2 OUTN.n0 12.9135
R41 OUTN.n0 OUTN.t1 5.8143
R42 OUTN.n0 OUTN.t3 5.76693
R43 OUTN.n1 OUTN.t0 5.73011
R44 OUTN.n1 OUTN.t2 5.68274
R45 OUTN.n2 OUTN.n1 4.5005
R46 OUTP OUTP.n2 26.1401
R47 OUTP.n2 OUTP.n0 12.6396
R48 OUTP.n0 OUTP.t2 5.8143
R49 OUTP.n0 OUTP.t1 5.76693
R50 OUTP.n1 OUTP.t3 5.73011
R51 OUTP.n1 OUTP.t0 5.68274
R52 OUTP.n2 OUTP.n1 4.77441
R53 VDD.t44 VDD.n53 191.112
R54 VDD.t46 VDD.n52 191.112
R55 VDD.n43 VDD.t0 191.112
R56 VDD.n65 VDD.t8 177.779
R57 VDD.t26 VDD.t2 168.889
R58 VDD.t22 VDD.t40 168.889
R59 VDD.t4 VDD.n54 155.556
R60 VDD.n42 VDD.t28 155.556
R61 VDD.t28 VDD.n41 117.412
R62 VDD.n55 VDD.t4 111.112
R63 VDD.n44 VDD.t6 111.112
R64 VDD.n64 VDD.n30 94.5005
R65 VDD.n35 VDD.n30 94.5005
R66 VDD.n57 VDD.n35 94.5005
R67 VDD.n57 VDD.n34 94.5005
R68 VDD.n51 VDD.n34 94.5005
R69 VDD.n51 VDD.n36 94.5005
R70 VDD.n45 VDD.n36 94.5005
R71 VDD.n45 VDD.n40 94.5005
R72 VDD.n41 VDD.n40 94.5005
R73 VDD.t6 VDD.t42 80.0005
R74 VDD.n65 VDD.n64 72.9672
R75 VDD.n3 VDD.t21 61.4885
R76 VDD.n20 VDD.t14 61.4885
R77 VDD.n3 VDD.t17 61.4598
R78 VDD.n20 VDD.t10 61.4598
R79 VDD.t11 VDD.n55 57.7783
R80 VDD.n56 VDD.t32 57.7783
R81 VDD.n53 VDD.t30 57.7783
R82 VDD.n52 VDD.t34 57.7783
R83 VDD.t38 VDD.n43 57.7783
R84 VDD.n44 VDD.t18 57.7783
R85 VDD.n66 VDD.n65 26.4219
R86 VDD.n2 VDD.t7 22.8342
R87 VDD.n54 VDD.t8 22.2227
R88 VDD.n56 VDD.t26 22.2227
R89 VDD.t40 VDD.n42 22.2227
R90 VDD.n19 VDD.t27 22.0289
R91 VDD.n1 VDD.t29 19.8328
R92 VDD.n14 VDD.n13 19.7238
R93 VDD.n16 VDD.n15 19.7238
R94 VDD.n18 VDD.n17 19.7238
R95 VDD.n12 VDD.n11 19.5343
R96 VDD.n28 VDD.t5 18.316
R97 VDD.n1 VDD.t41 18.2213
R98 VDD.n29 VDD.t9 18.0802
R99 VDD.n63 VDD.n0 18.0005
R100 VDD.n62 VDD.n61 18.0005
R101 VDD.n60 VDD.n31 18.0005
R102 VDD.n59 VDD.n58 18.0005
R103 VDD.n33 VDD.n32 18.0005
R104 VDD.n50 VDD.n49 18.0005
R105 VDD.n48 VDD.n37 18.0005
R106 VDD.n47 VDD.n46 18.0005
R107 VDD.t2 VDD.t11 17.7783
R108 VDD.t32 VDD.t44 17.7783
R109 VDD.t30 VDD.t46 17.7783
R110 VDD.t0 VDD.t34 17.7783
R111 VDD.t42 VDD.t38 17.7783
R112 VDD.t18 VDD.t22 17.7783
R113 VDD.n5 VDD.n3 16.5483
R114 VDD.n22 VDD.n20 16.5483
R115 VDD.n9 VDD.n8 10.2574
R116 VDD.n26 VDD.n25 10.2574
R117 VDD.n5 VDD.n4 10.0565
R118 VDD.n22 VDD.n21 10.0565
R119 VDD.n47 VDD.n38 9.42313
R120 VDD.n10 VDD.n9 8.25702
R121 VDD.n27 VDD.n26 8.25702
R122 VDD.n41 VDD.n38 6.96266
R123 VDD.n64 VDD.n63 6.3005
R124 VDD.n54 VDD.n30 6.3005
R125 VDD.n62 VDD.n30 6.3005
R126 VDD.n55 VDD.n35 6.3005
R127 VDD.n35 VDD.n31 6.3005
R128 VDD.n57 VDD.n56 6.3005
R129 VDD.n58 VDD.n57 6.3005
R130 VDD.n53 VDD.n34 6.3005
R131 VDD.n34 VDD.n33 6.3005
R132 VDD.n52 VDD.n51 6.3005
R133 VDD.n51 VDD.n50 6.3005
R134 VDD.n43 VDD.n36 6.3005
R135 VDD.n37 VDD.n36 6.3005
R136 VDD.n45 VDD.n44 6.3005
R137 VDD.n46 VDD.n45 6.3005
R138 VDD.n42 VDD.n40 6.3005
R139 VDD.n40 VDD.n39 6.3005
R140 VDD.n6 VDD.t24 5.98783
R141 VDD.n23 VDD.t16 5.98783
R142 VDD.n6 VDD.t20 5.79836
R143 VDD.n23 VDD.t13 5.79836
R144 VDD.n67 VDD.n66 5.21103
R145 VDD.n7 VDD.n6 4.61892
R146 VDD.n24 VDD.n23 4.61892
R147 VDD.n29 VDD.n28 1.65839
R148 VDD.n12 VDD.n10 1.46892
R149 VDD.n19 VDD.n18 1.42155
R150 VDD.n18 VDD.n16 1.42155
R151 VDD.n16 VDD.n14 1.42155
R152 VDD.n63 VDD.n62 1.3505
R153 VDD.n62 VDD.n31 1.3505
R154 VDD.n58 VDD.n31 1.3505
R155 VDD.n58 VDD.n33 1.3505
R156 VDD.n50 VDD.n33 1.3505
R157 VDD.n50 VDD.n37 1.3505
R158 VDD.n46 VDD.n37 1.3505
R159 VDD.n46 VDD.n39 1.3505
R160 VDD.n14 VDD.n12 0.711026
R161 VDD.n9 VDD.n7 0.704848
R162 VDD.n26 VDD.n24 0.704848
R163 VDD.n66 VDD.n29 0.687342
R164 VDD.n27 VDD.n19 0.663658
R165 VDD.n10 VDD.n2 0.663658
R166 VDD.n39 VDD.n38 0.641316
R167 VDD.n61 VDD.n0 0.6005
R168 VDD.n61 VDD.n60 0.6005
R169 VDD.n60 VDD.n59 0.6005
R170 VDD.n59 VDD.n32 0.6005
R171 VDD.n49 VDD.n32 0.6005
R172 VDD.n49 VDD.n48 0.6005
R173 VDD.n48 VDD.n47 0.6005
R174 VDD.n7 VDD.n5 0.470065
R175 VDD.n24 VDD.n22 0.470065
R176 VDD.n4 VDD.t19 0.4555
R177 VDD.n4 VDD.t23 0.4555
R178 VDD.n11 VDD.t39 0.4555
R179 VDD.n11 VDD.t43 0.4555
R180 VDD.n13 VDD.t35 0.4555
R181 VDD.n13 VDD.t1 0.4555
R182 VDD.n15 VDD.t31 0.4555
R183 VDD.n15 VDD.t47 0.4555
R184 VDD.n17 VDD.t33 0.4555
R185 VDD.n17 VDD.t45 0.4555
R186 VDD.n21 VDD.t12 0.4555
R187 VDD.n21 VDD.t15 0.4555
R188 VDD.n67 VDD.n0 0.309974
R189 VDD.n28 VDD.n27 0.284711
R190 VDD.n2 VDD.n1 0.237342
R191 VDD.n8 VDD.t25 0.152167
R192 VDD.n8 VDD.t36 0.152167
R193 VDD.n25 VDD.t37 0.152167
R194 VDD.n25 VDD.t3 0.152167
R195 VDD VDD.n67 0.0205
R196 VSS.n36 VSS.n35 478.473
R197 VSS.n50 VSS.t49 388.195
R198 VSS.n82 VSS.t22 361.111
R199 VSS.t25 VSS.t2 343.057
R200 VSS.t46 VSS.t16 343.057
R201 VSS.n64 VSS.t0 315.973
R202 VSS.n43 VSS.t27 315.973
R203 VSS.n42 VSS.t20 225.695
R204 VSS.t0 VSS.n63 225.695
R205 VSS.n36 VSS.t27 225.695
R206 VSS.n81 VSS.n2 207.639
R207 VSS.t29 VSS.t53 198.612
R208 VSS.t55 VSS.t39 198.612
R209 VSS.t20 VSS.t51 162.5
R210 VSS.n34 VSS.n19 138.25
R211 VSS.n82 VSS.n81 135.417
R212 VSS.n37 VSS.n21 129.5
R213 VSS.n63 VSS.t5 117.362
R214 VSS.t52 VSS.n56 117.362
R215 VSS.n57 VSS.t48 117.362
R216 VSS.n50 VSS.t54 117.362
R217 VSS.n49 VSS.t50 117.362
R218 VSS.t12 VSS.n42 117.362
R219 VSS.n108 VSS.t15 113.632
R220 VSS.n90 VSS.t8 113.632
R221 VSS.n108 VSS.t11 113.603
R222 VSS.n90 VSS.t4 113.603
R223 VSS.n26 VSS.n21 105.001
R224 VSS.n30 VSS.n29 105.001
R225 VSS.n34 VSS.n24 105.001
R226 VSS.n65 VSS.n1 105.001
R227 VSS.n65 VSS.n10 105.001
R228 VSS.n55 VSS.n10 105.001
R229 VSS.n55 VSS.n14 105.001
R230 VSS.n51 VSS.n14 105.001
R231 VSS.n51 VSS.n16 105.001
R232 VSS.n41 VSS.n16 105.001
R233 VSS.n41 VSS.n20 105.001
R234 VSS.n37 VSS.n20 105.001
R235 VSS.n73 VSS.n8 105.001
R236 VSS.n76 VSS.n75 105.001
R237 VSS.n80 VSS.n3 105.001
R238 VSS.n62 VSS.n3 105.001
R239 VSS.n62 VSS.n11 105.001
R240 VSS.n58 VSS.n11 105.001
R241 VSS.n58 VSS.n13 105.001
R242 VSS.n48 VSS.n13 105.001
R243 VSS.n48 VSS.n17 105.001
R244 VSS.n44 VSS.n17 105.001
R245 VSS.n44 VSS.n19 105.001
R246 VSS.n80 VSS.n4 85.7505
R247 VSS.n57 VSS.t41 81.2505
R248 VSS.t43 VSS.n49 81.2505
R249 VSS.n69 VSS.n1 77.0005
R250 VSS.n64 VSS.t22 45.1394
R251 VSS.n56 VSS.t25 45.1394
R252 VSS.n43 VSS.t46 45.1394
R253 VSS.t2 VSS.t5 36.1116
R254 VSS.t53 VSS.t52 36.1116
R255 VSS.t31 VSS.t29 36.1116
R256 VSS.t37 VSS.t31 36.1116
R257 VSS.t41 VSS.t37 36.1116
R258 VSS.t49 VSS.t48 36.1116
R259 VSS.t54 VSS.t55 36.1116
R260 VSS.t39 VSS.t35 36.1116
R261 VSS.t35 VSS.t33 36.1116
R262 VSS.t33 VSS.t43 36.1116
R263 VSS.t51 VSS.t50 36.1116
R264 VSS.t16 VSS.t12 36.1116
R265 VSS.n102 VSS.t21 26.9438
R266 VSS.n93 VSS.t26 26.9201
R267 VSS.n112 VSS.t28 26.0913
R268 VSS.n83 VSS.t23 26.0913
R269 VSS.n83 VSS.n82 25.7462
R270 VSS.n111 VSS.t47 24.8769
R271 VSS.n84 VSS.t1 24.8769
R272 VSS.n113 VSS.n0 18.3305
R273 VSS.n109 VSS.n108 16.1049
R274 VSS.n91 VSS.n90 16.1049
R275 VSS.n105 VSS.n103 12.3986
R276 VSS.n87 VSS.n85 12.3986
R277 VSS.n101 VSS.n100 11.3092
R278 VSS.n97 VSS.n96 11.3092
R279 VSS.n110 VSS.n109 10.2331
R280 VSS.n92 VSS.n91 10.2331
R281 VSS.n107 VSS.n106 9.98011
R282 VSS.n89 VSS.n88 9.98011
R283 VSS.n113 VSS.n112 6.06366
R284 VSS.n104 VSS.t18 5.7796
R285 VSS.n86 VSS.t10 5.7796
R286 VSS.n100 VSS.n99 5.66497
R287 VSS.n96 VSS.n95 5.66497
R288 VSS.n104 VSS.t14 5.59012
R289 VSS.n86 VSS.t7 5.59012
R290 VSS.n100 VSS.n98 5.4755
R291 VSS.n96 VSS.n94 5.4755
R292 VSS.n37 VSS.n36 5.2005
R293 VSS.n38 VSS.n37 5.2005
R294 VSS.n43 VSS.n20 5.2005
R295 VSS.n39 VSS.n20 5.2005
R296 VSS.n42 VSS.n41 5.2005
R297 VSS.n41 VSS.n40 5.2005
R298 VSS.n49 VSS.n16 5.2005
R299 VSS.n16 VSS.n15 5.2005
R300 VSS.n51 VSS.n50 5.2005
R301 VSS.n52 VSS.n51 5.2005
R302 VSS.n57 VSS.n14 5.2005
R303 VSS.n53 VSS.n14 5.2005
R304 VSS.n56 VSS.n55 5.2005
R305 VSS.n55 VSS.n54 5.2005
R306 VSS.n63 VSS.n10 5.2005
R307 VSS.n10 VSS.n9 5.2005
R308 VSS.n65 VSS.n64 5.2005
R309 VSS.n66 VSS.n65 5.2005
R310 VSS.n81 VSS.n1 5.2005
R311 VSS.n67 VSS.n1 5.2005
R312 VSS.n78 VSS.n4 5.2005
R313 VSS.n77 VSS.n76 5.2005
R314 VSS.n75 VSS.n6 5.2005
R315 VSS.n73 VSS.n72 5.2005
R316 VSS.n71 VSS.n8 5.2005
R317 VSS.n70 VSS.n69 5.2005
R318 VSS.n81 VSS.n80 5.2005
R319 VSS.n80 VSS.n79 5.2005
R320 VSS.n64 VSS.n3 5.2005
R321 VSS.n5 VSS.n3 5.2005
R322 VSS.n63 VSS.n62 5.2005
R323 VSS.n62 VSS.n61 5.2005
R324 VSS.n56 VSS.n11 5.2005
R325 VSS.n60 VSS.n11 5.2005
R326 VSS.n58 VSS.n57 5.2005
R327 VSS.n59 VSS.n58 5.2005
R328 VSS.n50 VSS.n13 5.2005
R329 VSS.n13 VSS.n12 5.2005
R330 VSS.n49 VSS.n48 5.2005
R331 VSS.n48 VSS.n47 5.2005
R332 VSS.n42 VSS.n17 5.2005
R333 VSS.n46 VSS.n17 5.2005
R334 VSS.n44 VSS.n43 5.2005
R335 VSS.n45 VSS.n44 5.2005
R336 VSS.n36 VSS.n19 5.2005
R337 VSS.n19 VSS.n18 5.2005
R338 VSS.n35 VSS.n21 5.2005
R339 VSS.n25 VSS.n21 5.2005
R340 VSS.n27 VSS.n26 5.2005
R341 VSS.n29 VSS.n28 5.2005
R342 VSS.n31 VSS.n30 5.2005
R343 VSS.n32 VSS.n24 5.2005
R344 VSS.n35 VSS.n34 5.2005
R345 VSS.n34 VSS.n33 5.2005
R346 VSS.n7 VSS.n4 4.73237
R347 VSS.n75 VSS.n74 4.73237
R348 VSS.n68 VSS.n8 4.73237
R349 VSS.n26 VSS.n23 4.73237
R350 VSS.n30 VSS.n22 4.73237
R351 VSS.n29 VSS.n23 4.73237
R352 VSS.n24 VSS.n22 4.73237
R353 VSS.n69 VSS.n68 4.73237
R354 VSS.n74 VSS.n73 4.73237
R355 VSS.n76 VSS.n7 4.73237
R356 VSS.n105 VSS.n104 4.5005
R357 VSS.n87 VSS.n86 4.5005
R358 VSS.n101 VSS.n97 2.84261
R359 VSS.n33 VSS.n18 1.778
R360 VSS.n67 VSS.n66 1.3505
R361 VSS.n66 VSS.n9 1.3505
R362 VSS.n54 VSS.n9 1.3505
R363 VSS.n54 VSS.n53 1.3505
R364 VSS.n53 VSS.n52 1.3505
R365 VSS.n52 VSS.n15 1.3505
R366 VSS.n40 VSS.n15 1.3505
R367 VSS.n40 VSS.n39 1.3505
R368 VSS.n39 VSS.n38 1.3505
R369 VSS.n71 VSS.n70 1.3505
R370 VSS.n72 VSS.n71 1.3505
R371 VSS.n72 VSS.n6 1.3505
R372 VSS.n77 VSS.n6 1.3505
R373 VSS.n78 VSS.n77 1.3505
R374 VSS.n79 VSS.n5 1.3505
R375 VSS.n61 VSS.n5 1.3505
R376 VSS.n61 VSS.n60 1.3505
R377 VSS.n60 VSS.n59 1.3505
R378 VSS.n59 VSS.n12 1.3505
R379 VSS.n47 VSS.n12 1.3505
R380 VSS.n47 VSS.n46 1.3505
R381 VSS.n46 VSS.n45 1.3505
R382 VSS.n45 VSS.n18 1.3505
R383 VSS.n27 VSS.n25 1.3505
R384 VSS.n28 VSS.n27 1.3505
R385 VSS.n31 VSS.n28 1.3505
R386 VSS.n32 VSS.n31 1.3505
R387 VSS.n33 VSS.n32 1.3505
R388 VSS.n107 VSS.n105 1.25267
R389 VSS.n89 VSS.n87 1.25267
R390 VSS.n38 VSS.n0 1.193
R391 VSS.n97 VSS.n93 1.18471
R392 VSS.n93 VSS.n92 1.13734
R393 VSS.n111 VSS.n110 1.13734
R394 VSS.n79 VSS.n78 1.103
R395 VSS.n102 VSS.n101 1.06629
R396 VSS.n70 VSS.n67 0.9905
R397 VSS.n84 VSS.n83 0.947868
R398 VSS.n112 VSS.n111 0.947868
R399 VSS.n110 VSS.n102 0.876816
R400 VSS.n92 VSS.n84 0.758395
R401 VSS.n25 VSS.n0 0.473
R402 VSS.n109 VSS.n107 0.293978
R403 VSS.n91 VSS.n89 0.293978
R404 VSS.n103 VSS.t19 0.2735
R405 VSS.n103 VSS.t24 0.2735
R406 VSS.n85 VSS.t45 0.2735
R407 VSS.n85 VSS.t3 0.2735
R408 VSS.n7 VSS.n2 0.235315
R409 VSS.n74 VSS.n2 0.235315
R410 VSS.n68 VSS.n2 0.235315
R411 VSS.n35 VSS.n23 0.235315
R412 VSS.n35 VSS.n22 0.235315
R413 VSS.n106 VSS.t13 0.20525
R414 VSS.n106 VSS.t17 0.20525
R415 VSS.n88 VSS.t6 0.20525
R416 VSS.n88 VSS.t9 0.20525
R417 VSS.n98 VSS.t34 0.1643
R418 VSS.n98 VSS.t44 0.1643
R419 VSS.n99 VSS.t40 0.1643
R420 VSS.n99 VSS.t36 0.1643
R421 VSS.n94 VSS.t38 0.1643
R422 VSS.n94 VSS.t42 0.1643
R423 VSS.n95 VSS.t30 0.1643
R424 VSS.n95 VSS.t32 0.1643
R425 VSS VSS.n113 0.0205
R426 a_1148_n800.n2 a_1148_n800.n1 23.5779
R427 a_1148_n800.n2 a_1148_n800.n0 12.054
R428 a_1148_n800.t3 a_1148_n800.n5 5.82877
R429 a_1148_n800.n3 a_1148_n800.t0 5.6393
R430 a_1148_n800.n5 a_1148_n800.n4 5.4755
R431 a_1148_n800.n3 a_1148_n800.n2 4.92682
R432 a_1148_n800.n1 a_1148_n800.t5 0.20525
R433 a_1148_n800.n1 a_1148_n800.t4 0.20525
R434 a_1148_n800.n0 a_1148_n800.t7 0.20525
R435 a_1148_n800.n0 a_1148_n800.t6 0.20525
R436 a_1148_n800.n5 a_1148_n800.n3 0.189974
R437 a_1148_n800.n4 a_1148_n800.t1 0.1643
R438 a_1148_n800.n4 a_1148_n800.t2 0.1643
R439 a_n3652_n800.n2 a_n3652_n800.n1 24.204
R440 a_n3652_n800.n2 a_n3652_n800.n0 12.054
R441 a_n3652_n800.t3 a_n3652_n800.n5 5.82877
R442 a_n3652_n800.n3 a_n3652_n800.t0 5.6393
R443 a_n3652_n800.n5 a_n3652_n800.n4 5.4755
R444 a_n3652_n800.n3 a_n3652_n800.n2 4.92682
R445 a_n3652_n800.n1 a_n3652_n800.t5 0.20525
R446 a_n3652_n800.n1 a_n3652_n800.t4 0.20525
R447 a_n3652_n800.n0 a_n3652_n800.t6 0.20525
R448 a_n3652_n800.n0 a_n3652_n800.t7 0.20525
R449 a_n3652_n800.n5 a_n3652_n800.n3 0.189974
R450 a_n3652_n800.n4 a_n3652_n800.t1 0.1643
R451 a_n3652_n800.n4 a_n3652_n800.t2 0.1643
R452 a_1004_n800.n3 a_1004_n800.t6 61.4885
R453 a_1004_n800.n1 a_1004_n800.t2 61.4885
R454 a_1004_n800.n3 a_1004_n800.t7 61.4598
R455 a_1004_n800.n1 a_1004_n800.t0 61.4598
R456 a_1004_n800.n4 a_1004_n800.n3 41.1196
R457 a_1004_n800.n2 a_1004_n800.n1 16.1049
R458 a_1004_n800.n4 a_1004_n800.n2 8.23746
R459 a_1004_n800.n0 a_1004_n800.t3 5.98783
R460 a_1004_n800.n0 a_1004_n800.t1 5.79836
R461 a_1004_n800.t5 a_1004_n800.n5 5.7796
R462 a_1004_n800.n5 a_1004_n800.t4 5.59012
R463 a_1004_n800.n2 a_1004_n800.n0 5.26354
R464 a_1004_n800.n5 a_1004_n800.n4 4.5005
R465 a_n3720_9000.n3 a_n3720_9000.t7 61.4885
R466 a_n3720_9000.n1 a_n3720_9000.t2 61.4885
R467 a_n3720_9000.n3 a_n3720_9000.t6 61.4598
R468 a_n3720_9000.n1 a_n3720_9000.t0 61.4598
R469 a_n3720_9000.n4 a_n3720_9000.n3 41.2501
R470 a_n3720_9000.n2 a_n3720_9000.n1 16.1049
R471 a_n3720_9000.n4 a_n3720_9000.n2 8.23746
R472 a_n3720_9000.n0 a_n3720_9000.t3 5.98783
R473 a_n3720_9000.n0 a_n3720_9000.t1 5.79836
R474 a_n3720_9000.t5 a_n3720_9000.n5 5.7796
R475 a_n3720_9000.n5 a_n3720_9000.t4 5.59012
R476 a_n3720_9000.n2 a_n3720_9000.n0 5.26354
R477 a_n3720_9000.n5 a_n3720_9000.n4 4.5005
R478 a_n4444_1746.n2 a_n4444_1746.t9 92.4439
R479 a_n4444_1746.n3 a_n4444_1746.t8 76.9821
R480 a_n4444_1746.n2 a_n4444_1746.t7 58.7421
R481 a_n4444_1746.n3 a_n4444_1746.t6 52.8115
R482 a_n4444_1746.n6 a_n4444_1746.t1 14.4221
R483 a_n4444_1746.n4 a_n4444_1746.n3 11.7201
R484 a_n4444_1746.n4 a_n4444_1746.n2 11.4657
R485 a_n4444_1746.n1 a_n4444_1746.t0 11.1074
R486 a_n4444_1746.n1 a_n4444_1746.n0 6.16354
R487 a_n4444_1746.n0 a_n4444_1746.t3 5.98783
R488 a_n4444_1746.n7 a_n4444_1746.n6 5.96789
R489 a_n4444_1746.n0 a_n4444_1746.t2 5.79836
R490 a_n4444_1746.t5 a_n4444_1746.n7 5.7796
R491 a_n4444_1746.n5 a_n4444_1746.n1 5.77224
R492 a_n4444_1746.n7 a_n4444_1746.t4 5.59012
R493 a_n4444_1746.n5 a_n4444_1746.n4 4.5005
R494 a_n4444_1746.n6 a_n4444_1746.n5 0.0983261
R495 a_7556_3130.n0 a_7556_3130.t3 144.392
R496 a_7556_3130.n0 a_7556_3130.t2 84.8135
R497 a_7556_3130.t1 a_7556_3130.n1 18.2696
R498 a_7556_3130.n1 a_7556_3130.t0 11.5544
R499 a_7556_3130.n1 a_7556_3130.n0 10.9766
R500 a_n9244_3330.n4 a_n9244_3330.t9 92.4439
R501 a_n9244_3330.n3 a_n9244_3330.t8 77.5952
R502 a_n9244_3330.n4 a_n9244_3330.t7 58.7421
R503 a_n9244_3330.n3 a_n9244_3330.t6 52.7985
R504 a_n9244_3330.n2 a_n9244_3330.t0 14.3273
R505 a_n9244_3330.n5 a_n9244_3330.n3 13.207
R506 a_n9244_3330.n1 a_n9244_3330.t1 11.0127
R507 a_n9244_3330.n5 a_n9244_3330.n4 10.6831
R508 a_n9244_3330.n1 a_n9244_3330.n0 6.16354
R509 a_n9244_3330.n0 a_n9244_3330.t3 5.98783
R510 a_n9244_3330.n2 a_n9244_3330.n1 5.87007
R511 a_n9244_3330.n0 a_n9244_3330.t2 5.79836
R512 a_n9244_3330.t5 a_n9244_3330.n7 5.7796
R513 a_n9244_3330.n7 a_n9244_3330.n6 5.75267
R514 a_n9244_3330.n7 a_n9244_3330.t4 5.59012
R515 a_n9244_3330.n6 a_n9244_3330.n5 4.5005
R516 a_n9244_3330.n6 a_n9244_3330.n2 0.215717
R517 a_n9316_3400.n0 a_n9316_3400.t3 144.392
R518 a_n9316_3400.n0 a_n9316_3400.t2 84.8135
R519 a_n9316_3400.t1 a_n9316_3400.n1 18.2696
R520 a_n9316_3400.n1 a_n9316_3400.n0 12.6983
R521 a_n9316_3400.n1 a_n9316_3400.t0 11.5544
R522 a_5880_2800.n0 a_5880_2800.t5 165.774
R523 a_5880_2800.n0 a_5880_2800.t4 165.745
R524 a_5880_2800.n1 a_5880_2800.t3 87.5599
R525 a_5880_2800.n1 a_5880_2800.t2 87.5312
R526 a_5880_2800.n2 a_5880_2800.n0 22.8783
R527 a_5880_2800.t1 a_5880_2800.n3 18.3129
R528 a_5880_2800.n2 a_5880_2800.n1 16.9305
R529 a_5880_2800.n3 a_5880_2800.t0 10.4377
R530 a_5880_2800.n3 a_5880_2800.n2 10.2722
R531 a_n7716_3200.n0 a_n7716_3200.t5 165.774
R532 a_n7716_3200.n0 a_n7716_3200.t4 165.745
R533 a_n7716_3200.n1 a_n7716_3200.t3 87.5599
R534 a_n7716_3200.n1 a_n7716_3200.t2 87.5312
R535 a_n7716_3200.n2 a_n7716_3200.n0 23.1914
R536 a_n7716_3200.t1 a_n7716_3200.n3 18.3129
R537 a_n7716_3200.n2 a_n7716_3200.n1 16.6175
R538 a_n7716_3200.n3 a_n7716_3200.n2 11.6809
R539 a_n7716_3200.n3 a_n7716_3200.t0 10.4377
C0 VDD OUTP 6.50799f
C1 VBIAS INN 3.28974f
C2 OUTN VDD 6.53443f
C3 INP INN 3.13146f
C4 INP VBIAS 0.45166f
C5 OUTN OUTP 1.3795f
C6 VBIAS VSS 6.86272f
C7 INN VSS 6.66111f
C8 INP VSS 6.82092f
C9 OUTN VSS 5.26935f
C10 OUTP VSS 9.97457f
C11 VDD VSS 0.69716p
C12 a_n7716_3200.n0 VSS 0.7567f
C13 a_n7716_3200.n1 VSS 0.32368f
C14 a_n7716_3200.n2 VSS 2.37459f
C15 a_n7716_3200.t0 VSS 0.5075f
C16 a_n7716_3200.n3 VSS 2.46364f
C17 a_n7716_3200.t1 VSS 1.57453f
C18 a_5880_2800.n0 VSS 0.77795f
C19 a_5880_2800.n1 VSS 0.3491f
C20 a_5880_2800.n2 VSS 2.35791f
C21 a_5880_2800.t0 VSS 0.53091f
C22 a_5880_2800.n3 VSS 2.37489f
C23 a_5880_2800.t1 VSS 1.65535f
C24 a_n9316_3400.n0 VSS 2.77179f
C25 a_n9316_3400.t0 VSS 0.26228f
C26 a_n9316_3400.n1 VSS 2.25084f
C27 a_n9316_3400.t1 VSS 0.98282f
C28 a_n9244_3330.t3 VSS 0.40413f
C29 a_n9244_3330.t2 VSS 0.39924f
C30 a_n9244_3330.n0 VSS 0.37165f
C31 a_n9244_3330.t1 VSS 0.53933f
C32 a_n9244_3330.n1 VSS 1.4348f
C33 a_n9244_3330.t0 VSS 0.2874f
C34 a_n9244_3330.n2 VSS 1.10718f
C35 a_n9244_3330.n3 VSS 3.01154f
C36 a_n9244_3330.n4 VSS 3.11973f
C37 a_n9244_3330.n5 VSS 2.69544f
C38 a_n9244_3330.n6 VSS 0.34477f
C39 a_n9244_3330.t4 VSS 0.8407f
C40 a_n9244_3330.n7 VSS 0.37313f
C41 a_n9244_3330.t5 VSS 0.84622f
C42 a_7556_3130.n0 VSS 2.42779f
C43 a_7556_3130.t0 VSS 0.25365f
C44 a_7556_3130.n1 VSS 1.94824f
C45 a_7556_3130.t1 VSS 0.94449f
C46 a_n4444_1746.t3 VSS 0.41793f
C47 a_n4444_1746.t2 VSS 0.41288f
C48 a_n4444_1746.n0 VSS 0.37952f
C49 a_n4444_1746.t0 VSS 0.59395f
C50 a_n4444_1746.n1 VSS 1.49188f
C51 a_n4444_1746.n2 VSS 3.23571f
C52 a_n4444_1746.n3 VSS 2.67243f
C53 a_n4444_1746.n4 VSS 2.68906f
C54 a_n4444_1746.n5 VSS 0.80618f
C55 a_n4444_1746.t1 VSS 0.32682f
C56 a_n4444_1746.n6 VSS 0.72419f
C57 a_n4444_1746.t4 VSS 0.88191f
C58 a_n4444_1746.n7 VSS 0.39373f
C59 a_n4444_1746.t5 VSS 0.88754f
C60 a_n3720_9000.t3 VSS 0.34029f
C61 a_n3720_9000.t1 VSS 0.33623f
C62 a_n3720_9000.n0 VSS 0.26601f
C63 a_n3720_9000.n1 VSS 0.18615f
C64 a_n3720_9000.n2 VSS 1.1572f
C65 a_n3720_9000.n3 VSS 1.76516f
C66 a_n3720_9000.n4 VSS 3.28259f
C67 a_n3720_9000.t4 VSS 0.73201f
C68 a_n3720_9000.n5 VSS 0.27296f
C69 a_n3720_9000.t5 VSS 0.73654f
C70 a_1004_n800.t3 VSS 0.38635f
C71 a_1004_n800.t1 VSS 0.38173f
C72 a_1004_n800.n0 VSS 0.30202f
C73 a_1004_n800.n1 VSS 0.21135f
C74 a_1004_n800.n2 VSS 1.31382f
C75 a_1004_n800.n3 VSS 1.85962f
C76 a_1004_n800.n4 VSS 3.73295f
C77 a_1004_n800.t4 VSS 0.79039f
C78 a_1004_n800.n5 VSS 0.3099f
C79 a_1004_n800.t5 VSS 0.79554f
C80 a_n3652_n800.t7 VSS 0.21352f
C81 a_n3652_n800.t6 VSS 0.21354f
C82 a_n3652_n800.n0 VSS 0.79846f
C83 a_n3652_n800.t4 VSS 0.23879f
C84 a_n3652_n800.t5 VSS 0.23882f
C85 a_n3652_n800.n1 VSS 1.38024f
C86 a_n3652_n800.n2 VSS 1.75332f
C87 a_n3652_n800.t0 VSS 1.08084f
C88 a_n3652_n800.n3 VSS 0.49672f
C89 a_n3652_n800.t2 VSS 0.23947f
C90 a_n3652_n800.t1 VSS 0.23947f
C91 a_n3652_n800.n4 VSS 0.8065f
C92 a_n3652_n800.n5 VSS 0.37782f
C93 a_n3652_n800.t3 VSS 1.08809f
C94 a_1148_n800.t6 VSS 0.21593f
C95 a_1148_n800.t7 VSS 0.21594f
C96 a_1148_n800.n0 VSS 0.81383f
C97 a_1148_n800.t4 VSS 0.2412f
C98 a_1148_n800.t5 VSS 0.24122f
C99 a_1148_n800.n1 VSS 1.34715f
C100 a_1148_n800.n2 VSS 1.66654f
C101 a_1148_n800.t0 VSS 1.10005f
C102 a_1148_n800.n3 VSS 0.50628f
C103 a_1148_n800.t2 VSS 0.24247f
C104 a_1148_n800.t1 VSS 0.24247f
C105 a_1148_n800.n4 VSS 0.82202f
C106 a_1148_n800.n5 VSS 0.38509f
C107 a_1148_n800.t3 VSS 1.10741f
C108 VSS.t23 VSS 0.05751f
C109 VSS.t1 VSS 0.06927f
C110 VSS.t3 VSS 0.08273f
C111 VSS.t45 VSS 0.08275f
C112 VSS.t26 VSS 0.05693f
C113 VSS.t42 VSS 0.08456f
C114 VSS.t38 VSS 0.08334f
C115 VSS.t32 VSS 0.08334f
C116 VSS.t30 VSS 0.08334f
C117 VSS.t44 VSS 0.08456f
C118 VSS.t34 VSS 0.08334f
C119 VSS.t36 VSS 0.08334f
C120 VSS.t40 VSS 0.08334f
C121 VSS.t21 VSS 0.06735f
C122 VSS.t24 VSS 0.08778f
C123 VSS.t19 VSS 0.0878f
C124 VSS.t47 VSS 0.06594f
C125 VSS.t28 VSS 0.05872f
C126 VDD.n0 VSS 0.06851f
C127 VDD.t29 VSS 0.20776f
C128 VDD.t41 VSS 0.22454f
C129 VDD.n1 VSS 0.24075f
C130 VDD.t7 VSS 0.22781f
C131 VDD.n2 VSS 0.12641f
C132 VDD.n3 VSS 0.0186f
C133 VDD.n4 VSS 0.02851f
C134 VDD.n5 VSS 0.02891f
C135 VDD.t24 VSS 0.0287f
C136 VDD.t20 VSS 0.02836f
C137 VDD.n6 VSS 0.02709f
C138 VDD.n7 VSS 0.01108f
C139 VDD.t36 VSS 0.17963f
C140 VDD.t25 VSS 0.17965f
C141 VDD.n8 VSS 0.07303f
C142 VDD.n9 VSS 0.07197f
C143 VDD.n10 VSS 0.07081f
C144 VDD.t43 VSS 0.05594f
C145 VDD.t39 VSS 0.05591f
C146 VDD.n11 VSS 0.06854f
C147 VDD.n12 VSS 0.12191f
C148 VDD.t1 VSS 0.05594f
C149 VDD.t35 VSS 0.05591f
C150 VDD.n13 VSS 0.07511f
C151 VDD.n14 VSS 0.12378f
C152 VDD.t47 VSS 0.04976f
C153 VDD.t31 VSS 0.04974f
C154 VDD.n15 VSS 0.07511f
C155 VDD.n16 VSS 0.14187f
C156 VDD.t45 VSS 0.04974f
C157 VDD.t33 VSS 0.04976f
C158 VDD.n17 VSS 0.07511f
C159 VDD.n18 VSS 0.14187f
C160 VDD.t27 VSS 0.18626f
C161 VDD.n19 VSS 0.1427f
C162 VDD.n20 VSS 0.0186f
C163 VDD.n21 VSS 0.02851f
C164 VDD.n22 VSS 0.02891f
C165 VDD.t16 VSS 0.0287f
C166 VDD.t13 VSS 0.02836f
C167 VDD.n23 VSS 0.02709f
C168 VDD.n24 VSS 0.01108f
C169 VDD.t3 VSS 0.17001f
C170 VDD.t37 VSS 0.17003f
C171 VDD.n25 VSS 0.07303f
C172 VDD.n26 VSS 0.07197f
C173 VDD.n27 VSS 0.04067f
C174 VDD.t5 VSS 0.23444f
C175 VDD.n28 VSS 0.10206f
C176 VDD.t9 VSS 0.18899f
C177 VDD.n29 VSS 0.10645f
C178 VDD.t8 VSS 1.60595f
C179 VDD.n30 VSS 0.07613f
C180 VDD.n31 VSS 0.07938f
C181 VDD.n32 VSS 0.08083f
C182 VDD.n33 VSS 0.07938f
C183 VDD.n34 VSS 0.07613f
C184 VDD.n35 VSS 0.07613f
C185 VDD.t34 VSS 0.60669f
C186 VDD.n36 VSS 0.07613f
C187 VDD.n37 VSS 0.07938f
C188 VDD.n38 VSS 0.1159f
C189 VDD.n39 VSS 0.07938f
C190 VDD.n40 VSS 0.07613f
C191 VDD.n41 VSS 5.0269f
C192 VDD.t28 VSS 2.42457f
C193 VDD.n42 VSS 1.43419f
C194 VDD.t40 VSS 1.53457f
C195 VDD.t22 VSS 1.49889f
C196 VDD.t18 VSS 0.60669f
C197 VDD.t0 VSS 1.67733f
C198 VDD.n43 VSS 1.99852f
C199 VDD.t38 VSS 0.60669f
C200 VDD.t42 VSS 0.78513f
C201 VDD.t6 VSS 1.54159f
C202 VDD.n44 VSS 1.36081f
C203 VDD.n45 VSS 0.07613f
C204 VDD.n46 VSS 0.07938f
C205 VDD.n47 VSS 0.25849f
C206 VDD.n48 VSS 0.08083f
C207 VDD.n49 VSS 0.08083f
C208 VDD.n50 VSS 0.07938f
C209 VDD.n51 VSS 0.07613f
C210 VDD.n52 VSS 2.00613f
C211 VDD.t46 VSS 1.6814f
C212 VDD.t30 VSS 0.60669f
C213 VDD.n53 VSS 1.99852f
C214 VDD.t44 VSS 1.67733f
C215 VDD.t32 VSS 0.60669f
C216 VDD.n54 VSS 1.43419f
C217 VDD.t4 VSS 2.14628f
C218 VDD.n55 VSS 1.35614f
C219 VDD.t11 VSS 0.60669f
C220 VDD.t2 VSS 1.50196f
C221 VDD.t26 VSS 1.54319f
C222 VDD.n56 VSS 0.64238f
C223 VDD.n57 VSS 0.07613f
C224 VDD.n58 VSS 0.07938f
C225 VDD.n59 VSS 0.08083f
C226 VDD.n60 VSS 0.08083f
C227 VDD.n61 VSS 0.08083f
C228 VDD.n62 VSS 0.07938f
C229 VDD.n63 VSS 0.07303f
C230 VDD.n64 VSS 2.51528f
C231 VDD.n65 VSS 2.20178f
C232 VDD.n66 VSS 0.06908f
C233 VDD.n67 VSS 0.0323f
C234 OUTP.t1 VSS 1.30824f
C235 OUTP.t2 VSS 1.30974f
C236 OUTP.n0 VSS 1.08008f
C237 OUTP.t0 VSS 0.63727f
C238 OUTP.t3 VSS 0.63862f
C239 OUTP.n1 VSS 0.32247f
C240 OUTP.n2 VSS 3.94659f
C241 OUTN.t3 VSS 1.69139f
C242 OUTN.t1 VSS 1.69338f
C243 OUTN.n0 VSS 1.47367f
C244 OUTN.t2 VSS 0.82235f
C245 OUTN.t0 VSS 0.82414f
C246 OUTN.n1 VSS 0.42284f
C247 OUTN.n2 VSS 3.1849f
C248 INP.n0 VSS 0.77555f
C249 INP.n1 VSS 0.56469f
C250 INP.n2 VSS 3.79285f
C251 INN.n0 VSS 0.9606f
C252 INN.n1 VSS 0.69699f
C253 INN.n2 VSS 5.06965f
C254 VBIAS.n0 VSS 0.12695f
C255 VBIAS.n1 VSS 0.07554f
C256 VBIAS.n2 VSS 0.08005f
C257 VBIAS.n3 VSS 0.08005f
C258 VBIAS.n4 VSS 0.07628f
C259 VBIAS.n5 VSS 0.24462f
C260 VBIAS.n6 VSS 0.12695f
C261 VBIAS.n7 VSS 0.07554f
C262 VBIAS.n8 VSS 0.08005f
C263 VBIAS.n9 VSS 0.08005f
C264 VBIAS.n10 VSS 0.07628f
C265 VBIAS.n11 VSS 0.11051f
C266 VBIAS.n12 VSS 1.97256f
.ends
