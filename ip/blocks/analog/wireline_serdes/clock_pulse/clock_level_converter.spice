* SPDX-License-Identifier: Apache-2.0
* Symmetric regenerative CML-clock to CMOS-clock converter.
.subckt clock_level_converter INP INN VBIAS VDD VSS OUTP OUTN
XDNL VSS VSS VSS VSS nfet_03v3 w=8u l=0.28u m=2
XDNR VSS VSS VSS VSS nfet_03v3 w=8u l=0.28u m=2
XDPL VDD VDD VDD VDD pfet_03v3 w=4u l=0.28u m=2
XDPR VDD VDD VDD VDD pfet_03v3 w=4u l=0.28u m=2

* Two input-swapped differential receivers keep CML loading symmetric.
XAPN AP INP TP VSS nfet_03v3 w=8u l=0.28u m=2
XADN AD INN TP VSS nfet_03v3 w=8u l=0.28u m=2
XATP TP VBIAS VSS VSS nfet_03v3 w=10u l=0.28u m=4
XADP AD AD VDD VDD pfet_03v3 w=4u l=0.28u m=2
XAPP AP AD VDD VDD pfet_03v3 w=4u l=0.28u m=2
XANN AN INN TN VSS nfet_03v3 w=8u l=0.28u m=2
XBDN BD INP TN VSS nfet_03v3 w=8u l=0.28u m=2
XATN TN VBIAS VSS VSS nfet_03v3 w=10u l=0.28u m=4
XBDP BD BD VDD VDD pfet_03v3 w=4u l=0.28u m=2
XANP AN BD VDD VDD pfet_03v3 w=4u l=0.28u m=2

* A deliberately weak, symmetric cross-coupled pair reinforces the two mirror
* outputs after the input stages establish their polarity.
XFPAP AP AN VDD VDD pfet_03v3 w=3u l=0.28u m=1
XFNAP AP AN VSS VSS nfet_03v3 w=1u l=0.28u m=1
XFPAN AN AP VDD VDD pfet_03v3 w=3u l=0.28u m=1
XFNAN AN AP VSS VSS nfet_03v3 w=1u l=0.28u m=1

* Isolation stages keep high-impedance mirror-node capacitance small.
XAPP1 AB AP VDD VDD pfet_03v3 w=4u l=0.28u m=1
XAPN1 AB AP VSS VSS nfet_03v3 w=2u l=0.28u m=1
XANP1 NB AN VDD VDD pfet_03v3 w=4u l=0.28u m=1
XANN1 NB AN VSS VSS nfet_03v3 w=2u l=0.28u m=1
XAMP AC AB VDD VDD pfet_03v3 w=8u l=0.28u m=1
XAMN AC AB VSS VSS nfet_03v3 w=4u l=0.28u m=1
XNMP NC NB VDD VDD pfet_03v3 w=8u l=0.28u m=1
XNMN NC NB VSS VSS nfet_03v3 w=4u l=0.28u m=1
XOPP OUTP AC VDD VDD pfet_03v3 w=12u l=0.28u m=2
XOPN OUTP AC VSS VSS nfet_03v3 w=6u l=0.28u m=2
XONP OUTN NC VDD VDD pfet_03v3 w=12u l=0.28u m=2
XONN OUTN NC VSS VSS nfet_03v3 w=6u l=0.28u m=2
.ends clock_level_converter
