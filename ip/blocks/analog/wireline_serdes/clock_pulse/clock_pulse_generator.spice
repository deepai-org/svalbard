* SPDX-License-Identifier: Apache-2.0
* Calibrated dual-edge sense/write pulse generator for the regenerative RX.

.subckt cp_inv A Y VDD VSS params: WP=1.2u WN=0.6u MP=1 MN=1
XP Y A VDD VDD pfet_03v3 w={WP} l=0.28u m={MP}
XN Y A VSS VSS nfet_03v3 w={WN} l=0.28u m={MN}
.ends cp_inv

* The final write bank has a dedicated hierarchical VDD pin.  The parent
* straps VDDW to VDD, but the macro does not force pulse current through its
* single left-edge logic-supply access.
.subckt cp_final_inv A Y VDD VDDW VSS params: WP=8u WN=8u MP=30 MN=20
XP Y A VDDW VDD pfet_03v3 w={WP} l=0.28u m={MP}
XN Y A VSS VSS nfet_03v3 w={WN} l=0.28u m={MN}
.ends cp_final_inv

* The final sense pull-down likewise exposes a local ground pin while keeping
* the NMOS body on the continuous global-VSS substrate connection.
.subckt cp_sense_final_inv A Y VDD VSS VSSS params: WP=8u WN=8u MP=10 MN=8
XP Y A VDD VDD pfet_03v3 w={WP} l=0.28u m={MP}
XN Y A VSSS VSS nfet_03v3 w={WN} l=0.28u m={MN}
.ends cp_sense_final_inv

.subckt cp_nand2 A B Y VDD VSS params: WP=1.6u WN=1.2u MP=1 MN=1
XP0 Y A VDD VDD pfet_03v3 w={WP} l=0.28u m={MP}
XP1 Y B VDD VDD pfet_03v3 w={WP} l=0.28u m={MP}
XN0 Y A NS VSS nfet_03v3 w={WN} l=0.28u m={MN}
XN1 NS B VSS VSS nfet_03v3 w={WN} l=0.28u m={MN}
.ends cp_nand2

.subckt cp_nor2 A B Y VDD VSS params: WP=8u WN=8u MP=6 MN=2
XP0 NP A VDD VDD pfet_03v3 w={WP} l=0.28u m={MP}
XP1 Y B NP VDD pfet_03v3 w={WP} l=0.28u m={MP}
XN0 Y A VSS VSS nfet_03v3 w={WN} l=0.28u m={MN}
XN1 Y B VSS VSS nfet_03v3 w={WN} l=0.28u m={MN}
.ends cp_nor2

* Full-restoration NOR for sub-cycle pulse formation.  A direct CMOS NOR has
* stacked PMOS devices on its time-critical rising edge; under extracted load
* a 130-ps valid input window only charged the output to about 1.3 V.
.subckt cp_nor_fast A B Y VDD VSS
XIA A AB VDD VSS cp_inv WP=8u WN=8u MP=1 MN=1
XIB B BB VDD VSS cp_inv WP=8u WN=8u MP=1 MN=1
XN AB BB YB VDD VSS cp_nand2 WP=8u WN=8u MP=3 MN=3
XIY YB Y VDD VSS cp_inv WP=8u WN=8u MP=4 MN=3
.ends cp_nor_fast

.subckt cp_delay_unit A Y VDD VSS params: WP=2.2u WN=1.1u MP=1 MN=1
XD0 A DI VDD VSS cp_inv WP={WP} WN={WN} MP={MP} MN={MN}
XD1 DI Y VDD VSS cp_inv WP={WP} WN={WN} MP={MP} MN={MN}
.ends cp_delay_unit

* Profile-3 needs less end-path delay after the slow-corner source has been
* restored.  Keep the first-stage input load unchanged and double only the
* second-stage drive so the start/end spacing shrinks without moving the
* upstream source threshold or changing other calibration profiles.
.subckt cp_profile3_delay A Y VDD VSS
XD0 A DI VDD VSS cp_inv WP=15.5u WN=8.75u
XD1 DI Y VDD VSS cp_inv WP=15.5u WN=8.75u MP=2 MN=2
.ends cp_profile3_delay

* Four-inverter HCLK sense delay with a selectively slower final falling edge.
* The 1.3-um final NMOS interpolates between the extracted four-inverter pulse
* (too short to restore) and six-inverter pulse (about 50 ps too wide).
.subckt cp_sense_tail_delay A Y VDD VSS
XD0 A DI VDD VSS cp_inv WP=4u WN=2u MP=2 MN=2
XD1 DI Y VDD VSS cp_inv WP=4u WN=1.3u MP=2 MN=2
.ends cp_sense_tail_delay

* Write interval termination keeps a normal first-stage input load and adds
* only one PMOS finger to the second stage, advancing the delayed rising edge
* without moving the restored start edge.
.subckt cp_write_end_delay A Y VDD VSS
XD0 A DI VDD VSS cp_inv WP=4u WN=2u MP=2 MN=2
XD1 DI Y VDD VSS cp_inv WP=4u WN=2u MP=3 MN=2
.ends cp_write_end_delay

* Non-inverting edge shaper.  The falling output edge is deliberately slower
* than the rising edge, moving the SENSE leading edge later without consuming
* its recovery interval or changing logic thresholds.
.subckt cp_sense_edge_delay A Y VDD VSS
XD0 A DI VDD VSS cp_inv WP=8u WN=8u MP=4 MN=4
XD1 DI Y VDD VSS cp_inv WP=8u WN=8u MP=8 MN=8
.ends cp_sense_edge_delay

.subckt cp_tap_buffer A Y VDD VSS params: WP0=2u WN0=1u WP1=4u WN1=2u MN2=2
XI0 A B0 VDD VSS cp_inv WP={WP0} WN={WN0}
XI1 B0 B1 VDD VSS cp_inv WP={WP1} WN={WN1}
XI2 B1 B2 VDD VSS cp_inv WP=8u WN=6u MP=2 MN={MN2}
XI3 B2 Y VDD VSS cp_inv WP=8u WN=8u MP=4 MN=3
.ends cp_tap_buffer

* SSEL is already a static-CMOS restored node.  A second four-stage restorer
* added roughly 287 ps of extracted fall-edge latency and collapsed the odd
* low-overlap interval.  This two-stage path uses a 10-um restoring input and
* the same final drive as cp_tap_buffer without duplicating restoration.
.subckt cp_fast_tap_buffer A Y VDD VSS
XI0 A B0 VDD VSS cp_inv WP=6u WN=4u
XI1 B0 Y VDD VSS cp_inv WP=8u WN=8u MP=4 MN=2
.ends cp_fast_tap_buffer

* Profile 0 needs a slightly later CT falling edge at fast/cold, while the
* slow/hot profile needs substantially more pull-down.  FAST is SEL0B and is
* static while clocks run; the conditional series branch changes physical
* drive rather than inserting an ideal simulator delay.
.subckt cp_profile_tap_buffer A FAST Y VDD VSS
XI0 A B0 VDD VSS cp_inv WP=6u WN=4u
XI1 B0 Y VDD VSS cp_inv WP=8u WN=5.5u MP=4 MN=2
XNF Y B0 FAST VSS cp_cond_npd WG=8u WE=8u M=1
.ends cp_profile_tap_buffer

.subckt cp_sense_tap_buffer A Y VDD VSS
XI0 A B0 VDD VSS cp_inv WP=6u WN=4u
XI1 B0 Y VDD VSS cp_inv WP=8u WN=8u MP=2 MN=3
.ends cp_sense_tap_buffer

.subckt cp_fast_delay A Y VDD VSS
XI0 A B0 VDD VSS cp_inv WP=8u WN=8u MP=4 MN=5
XI1 B0 Y VDD VSS cp_inv WP=8u WN=8u MP=10 MN=4
.ends cp_fast_delay

.subckt cp_ultrafast_delay A Y VDD VSS
XI0 A B0 VDD VSS cp_inv WP=8u WN=8u MP=4 MN=4
XI1 B0 Y VDD VSS cp_inv WP=8u WN=8u MP=8 MN=8
.ends cp_ultrafast_delay

.subckt cp_cond_npd D G EN VSS params: WG=0.6u WE=3u M=1
XN0 D G N VSS nfet_03v3 w={WG} l=0.28u m={M}
XN1 N EN VSS VSS nfet_03v3 w={WE} l=0.28u m={M}
.ends cp_cond_npd

.subckt cp_gate_cap A VSS params: W=0.4u M=1
XN VSS A VSS VSS nfet_03v3 w={W} l=0.28u m={M}
.ends cp_gate_cap

* Minimum-size all-diffusion/gate route anchor.  Drain, gate, and source share
* the signal, while the well remains at VSS; this preserves a geometric route
* endpoint without needing a competing local VSS access segment.
.subckt cp_route_anchor A VSS params: W=0.4u
XN A A A VSS nfet_03v3 w={W} l=0.28u m=1
.ends cp_route_anchor

* Restore each tap before the selector so an analog pass node never has to
* drive four branches plus a threshold-sensitive receiver.  Start and end use
* the same stages; their selected tap spacing, not ratioed thresholds, defines
* pulse width.
.subckt cp_tristate_inv A Y EN ENB VDD VSS params: WP=8u WN=4u M=2
XP0 NP A VDD VDD pfet_03v3 w={WP} l=0.28u m={M}
XP1 Y ENB NP VDD pfet_03v3 w={WP} l=0.28u m={M}
XN0 NN A VSS VSS nfet_03v3 w={WN} l=0.28u m={M}
XN1 Y EN NN VSS nfet_03v3 w={WN} l=0.28u m={M}
.ends cp_tristate_inv

.subckt cp_select_prebuffer A Y VDD VSS params: WP0=2u WN0=1u WP1=8u WN1=4u MPP=1 MNN=1
XI0 A B0 VDD VSS cp_inv WP={WP0} WN={WN0}
XI1 B0 Y VDD VSS cp_inv WP={WP1} WN={WN1} MP={MPP} MN={MNN}
.ends cp_select_prebuffer

.subckt cp_write_restore A Y VDD VSS params: WP0=8u MP0=2 MN0=2 MP1=3 MN1=4
XI0 A B1 VDD VSS cp_inv WP={WP0} WN=4u MP={MP0} MN={MN0}
XI1 B1 Y VDD VSS cp_inv WP=8u WN=6u MP={MP1} MN={MN1}
.ends cp_write_restore

* Profile-qualified end-restorer branch.  Besides reinforcing B1 when the
* selected slow-corner edge is valid, its realized input/diffusion load is
* part of the calibrated nominal write interval and is retained in extraction.
.subckt cp_profile_write_restore A FAST Y VDD VSS
XI0 A B1 VDD VSS cp_inv WP=8u WN=4u MP=2 MN=2
XI1 B1 Y VDD VSS cp_inv WP=8u WN=6u MP=3 MN=4
XNF B1 A FAST VSS cp_cond_npd WG=2u WE=8u M=1
.ends cp_profile_write_restore

.subckt cp_tg A Y EN ENB VDD VSS params: W=4u M=2
XN Y EN A VSS nfet_03v3 w={W} l=0.28u m={M}
XP Y ENB A VDD pfet_03v3 w={W} l=0.28u m={M}
.ends cp_tg

* Active-low pulse while the earlier tap A is high and later tap B is low.
.subckt cp_rise_b A B YB VDD VSS
XI B BN VDD VSS cp_inv WP=8u WN=9u MP=2 MN=2
XN A BN YB VDD VSS cp_nand2 WP=8u WN=8u MP=9 MN=7
.ends cp_rise_b

* Compact active-low interval detector for two rising, full-swing timing
* edges. YB falls when A has risen but its delayed replica B has not, then
* returns high when B rises. It feeds an inverting three-stage output taper.
.subckt cp_rise_b_small A B YB VDD VSS
XI B BN VDD VSS cp_inv WP=4u WN=4u MP=2 MN=2
XN A BN YB VDD VSS cp_nand2 WP=4u WN=4u MP=2 MN=4
.ends cp_rise_b_small

* High only between the falling edges of an early full-width clock A and its
* later replica B.  Both inputs first feed ordinary static CMOS gates; this is
* deliberately not a simulator delay or a thresholded behavioral source.
* Profile 3 uses it because the legacy D03 timing node does not cross a valid
* logic threshold at SS/hot, while the separately restored P06S/P09S path does.
.subckt cp_fall_pulse A B Y VDD VSS
XIA A AB VDD VSS cp_inv WP=8u WN=8u
XN B AB YB VDD VSS cp_nand2 WP=8u WN=8u MP=3 MN=3
XIY YB Y VDD VSS cp_inv WP=8u WN=8u MP=4 MN=3
.ends cp_fall_pulse

* Reset-dominant interval latch. S rises before R and sets Q; when R rises the
* latch resets even though S remains high. S then falls before R, returning the
* cross-coupled NOR pair to its unique Q=0, QB=1 idle state. Unlike a narrow
* combinational glitch, Q is a regenerated state node that only drives a small
* geometric taper input.
.subckt cp_write_latch S R Q QB VDD VSS
XQ R QB Q VDD VSS cp_nor2 WP=8u WN=8u MP=3 MN=2
XQB S Q QB VDD VSS cp_nor2 WP=8u WN=8u MP=3 MN=4
.ends cp_write_latch

.subckt cp_phase CLK HCLK SEL0 SEL1 SEL2 SEL3 Q2RESET VDD VDDW VSS VSSS
+ SENSE BOOST WRITE
+ params: SB2_WN=8u SB2_MN=8
* SENSE and BOOST use the dedicated full-swing parent clock rather than the
* legacy selectable delay line. A physical two-unit delay defines the
* falling-edge interval, and WRITE is timed from the restored SENSE boundary.
XHSD0 HCLK HSM VDD VSS cp_delay_unit WP=4u WN=2u MP=2 MN=2
XHSD1 HSM HSD VDD VSS cp_sense_tail_delay
XHSN HCLK HSD HSN VDD VSS cp_fall_pulse
XSB0 HSN SB0 VDD VSS cp_inv WP=8u WN=10u MP=2 MN=2
XSB1 SB0 SB1 VDD VSS cp_inv WP=8u WN=8u MP=8 MN=4
XSB2 SB1 SENSE VDD VSS VSSS cp_sense_final_inv WP=8u WN={SB2_WN} MP=10 MN={SB2_MN}
XRB0 HSN RB0 VDD VSS cp_inv WP=8u WN=4u
XRB1 RB0 RB1 VDD VSS cp_inv WP=8u WN=6u MP=3 MN=2
XRB2 RB1 BOOST VDD VSS cp_inv WP=8u WN=8u MP=5 MN=3
* The shared-gate taper avoids the shoot-through interval of independently
* driven pull-up/pull-down banks. Its roughly 2x stage ratios support the
* larger final PMOS without placing that full gate load on a small predriver.
* Derive WRITE from a local replica of the restored SENSE boundary, never from
* the externally loaded SENSE net or the high-impedance HSN source.  The
* actual direct-regenerative SENSE/BOOST PEX previously left SENSE high yet
* erased WRITE through this shared timing input.  This small local replica
* preserves the same logical boundary while isolating the interval generator
* from its consumer's dynamic input network.  Its physical route is deliberately
* kept after the SENSE final driver so the isolated path retains non-overlap.
* This isolated replica drives its calibrated local load, not the lane.  Its
* modestly larger final bank is deliberately before the isolated boundary, so
* any future PVT benefit does not increase the external SENSE driver's lane
* coupling.
XWSRC SB1 WSRC VDD VSS cp_inv WP=8u WN=8u MP=2 MN=2
* Recreate the removed consumer-side timing load locally.  This explicit MOS
* gate capacitance keeps the isolated edge out of the SENSE aperture without
* reconnecting the interval generator to the downstream lane's PEX network.
XWSRCC WSRC VSS cp_gate_cap W=10u M=7
XWISO0 WSRC WSIB VDD VSS cp_inv WP=4u WN=4u
XWISO1 WSIB WSA VDD VSS cp_inv WP=2u WN=6u
XWISO2 WSA WSB VDD VSS cp_inv WP=6u WN=4u MP=2 MN=1
XWBASE WSB WBA VDD VSS cp_delay_unit WP=4u WN=2u MP=2 MN=2
XWSD0 WBA WSD VDD VSS cp_write_end_delay
XWPN WBA WSD WPN VDD VSS cp_rise_b_small
XWB0 WPN WB1 VDD VSS cp_inv WP=4u WN=4u MP=2 MN=2
XWB1 WB1 WB2 VDD VSS cp_inv WP=4u WN=4u MP=4 MN=4
XWB2 WB2 WB3 VDD VSS cp_inv WP=8u WN=8u MP=4 MN=4
XWB3 WB3 WB4 VDD VSS cp_inv WP=8u WN=8u MP=8 MN=8
XWB4 WB4 WRITE VDD VDDW VSS cp_final_inv WP=8u WN=8u MP=28 MN=22
* Preserve the parent interface while a real calibration path is designed.
* These minimum gate capacitors are route anchors, not timing elements: SEL
* codes must not be reported as calibration coverage until a physical path
* changes the emitted timing/drive behavior.
XACLK CLK VSS cp_gate_cap W=0.4u
XASEL0 SEL0 VSS cp_gate_cap W=0.4u
XASEL1 SEL1 VSS cp_gate_cap W=0.4u
XASEL2 SEL2 VSS cp_gate_cap W=0.4u
XASEL3 SEL3 VSS cp_gate_cap W=0.4u
XAQ2 Q2RESET VSS cp_gate_cap W=0.4u
.ends cp_phase

.subckt clock_pulse_generator CLKP CLKN SEL0 SEL1 SEL2 SEL3 VDD VSS
+ VDD_WE VDD_WO VSS_SE VSS_SO CLKP_H CLKN_H
+ E_SENSE E_BOOST E_WRITE
+ O_SENSE O_BOOST O_WRITE
XE CLKP CLKP_H SEL0 SEL1 SEL2 SEL3 SEL2 VDD VDD_WE VSS VSS_SE
+ E_SENSE E_BOOST E_WRITE cp_phase SB2_WN=6.5u SB2_MN=8
XO CLKN CLKN_H SEL0 SEL1 SEL2 SEL3 VSS VDD VDD_WO VSS VSS_SO
+ O_SENSE O_BOOST O_WRITE cp_phase SB2_WN=6.5u SB2_MN=8
.ends clock_pulse_generator
