* SPDX-License-Identifier: Apache-2.0
* Full-duty event bridge with balanced XCB0 and retapered final CLK drive.
*
* XCLK m=8 presents 136 um of gate width to XCK1 while driving the extracted
* capture cell's roughly 128-um CLK gate bank. The earlier m=16 stage was
* inherited from narrow-pulse regeneration and was larger than its real load.

.subckt ecb_inv A Y VDD VSS params: WP=8u WN=4u MP=1 MN=1
XP Y A VDD VDD pfet_03v3 w={WP} l=0.28u m={MP}
XN Y A VSS VSS nfet_03v3 w={WN} l=0.28u m={MN}
.ends ecb_inv

.subckt event_capture_phase START END CLK CLKB VDD VSS
XCB0 START STARTB VDD VSS ecb_inv WP=5u WN=2.75u MP=2 MN=2
XCLKB STARTB CLKB VDD VSS ecb_inv WP=8u WN=10u MP=8 MN=8
XCK0 END ENDB VDD VSS ecb_inv WP=8u WN=4u MP=2 MN=2
XCK1 ENDB ENDR VDD VSS ecb_inv WP=8u WN=5u MP=6 MN=6
XCLK ENDR CLK VDD VSS ecb_inv WP=12u WN=5u MP=8 MN=8
.ends event_capture_phase

.subckt event_capture_bridge E_START E_END O_START O_END
+ E_CAPTURE_CLK E_CAPTURE_CLKB O_CAPTURE_CLK O_CAPTURE_CLKB VDD VSS
XE E_START E_END E_CAPTURE_CLK E_CAPTURE_CLKB VDD VSS event_capture_phase
XO O_START O_END O_CAPTURE_CLK O_CAPTURE_CLKB VDD VSS event_capture_phase
.ends event_capture_bridge
