* PEX produced using /foss/tools/sak/sak-pex.sh with m=3 and s=1 (extresist threshold=0 mOhm, minres=1 mOhm, mindelay=0 ps)
* NGSPICE file created from local_clock_fanout_pex.ext - technology: gf180mcuD

.subckt local_clock_fanout_pex CLKP_H CLKP_HB CLKN_H CLKN_HB VDD VSS E_SENSE E_CAPTURE_CLK
+ E_CAPTURE_CLKB O_SENSE O_CAPTURE_CLK O_CAPTURE_CLKB
X0 VSS.t15 a_2700_41600.t11 O_CAPTURE_CLKB.t2 VSS.t14 nfet_03v3 ad=2.08p pd=8.52u as=2.08p ps=8.52u w=8u l=0.28u
X1 a_6924_41600.t5 CLKN_H.t10 VSS.t201 VSS.t200 nfet_03v3 ad=2.08p pd=8.52u as=2.08p ps=8.52u w=8u l=0.28u
X2 VSS.t29 a_6924_41600.t35 O_SENSE.t12 VSS.t28 nfet_03v3 ad=2.08p pd=8.52u as=2.08p ps=8.52u w=8u l=0.28u
X3 VDD.t13 a_6924_41600.t65 O_SENSE.t3 VDD.t12 pfet_03v3 ad=2.08p pd=8.52u as=2.08p ps=8.52u w=8u l=0.28u
X4 VSS.t35 a_4812_41600.t15 O_CAPTURE_CLK.t1 VSS.t34 nfet_03v3 ad=2.08p pd=8.52u as=3.52p ps=16.88u w=8u l=0.28u
X5 VSS.t125 a_6924_41600.t47 O_SENSE.t47 VSS.t124 nfet_03v3 ad=2.08p pd=8.52u as=2.08p ps=8.52u w=8u l=0.28u
X6 VSS.t241 CLKP_H.t13 a_6924_6400.t2 VSS.t240 nfet_03v3 ad=2.08p pd=8.52u as=2.08p ps=8.52u w=8u l=0.28u
X7 VDD.t33 a_6924_41600.t77 O_SENSE.t7 VDD.t32 pfet_03v3 ad=2.08p pd=8.52u as=2.08p ps=8.52u w=8u l=0.28u
X8 O_SENSE.t31 a_6924_41600.t32 VSS.t85 VSS.t84 nfet_03v3 ad=3.52p pd=16.88u as=2.08p ps=8.52u w=8u l=0.28u
X9 a_6924_6400.t17 CLKP_H.t34 VDD.t229 VDD.t228 pfet_03v3 ad=2.08p pd=8.52u as=2.08p ps=8.52u w=8u l=0.28u
X10 E_CAPTURE_CLK.t6 a_4812_6400.t16 VDD.t85 VDD.t84 pfet_03v3 ad=3.52p pd=16.88u as=2.08p ps=8.52u w=8u l=0.28u
X11 E_SENSE.t26 a_6924_6400.t64 VDD.t105 VDD.t104 pfet_03v3 ad=3.52p pd=16.88u as=2.08p ps=8.52u w=8u l=0.28u
X12 VSS.t129 a_6924_41600.t41 O_SENSE.t49 VSS.t128 nfet_03v3 ad=2.08p pd=8.52u as=2.08p ps=8.52u w=8u l=0.28u
X13 O_SENSE.t41 a_6924_41600.t74 VDD.t149 VDD.t148 pfet_03v3 ad=2.08p pd=8.52u as=2.08p ps=8.52u w=8u l=0.28u
X14 VDD.t99 a_6924_41600.t71 O_SENSE.t21 VDD.t98 pfet_03v3 ad=2.08p pd=8.52u as=2.08p ps=8.52u w=8u l=0.28u
X15 VSS.t115 a_6924_41600.t53 O_SENSE.t42 VSS.t114 nfet_03v3 ad=2.08p pd=8.52u as=2.08p ps=8.52u w=8u l=0.28u
X16 VSS.t281 a_2700_6400.t13 E_CAPTURE_CLKB.t15 VSS.t280 nfet_03v3 ad=2.08p pd=8.52u as=2.08p ps=8.52u w=8u l=0.28u
X17 O_CAPTURE_CLKB.t11 a_2700_41600.t22 VDD.t113 VDD.t112 pfet_03v3 ad=2.08p pd=8.52u as=2.08p ps=8.52u w=8u l=0.28u
X18 VDD.t227 CLKP_H.t35 a_6924_6400.t16 VDD.t226 pfet_03v3 ad=2.08p pd=8.52u as=3.52p ps=16.88u w=8u l=0.28u
X19 VDD.t147 a_6924_41600.t83 O_SENSE.t40 VDD.t146 pfet_03v3 ad=2.08p pd=8.52u as=2.08p ps=8.52u w=8u l=0.28u
X20 O_SENSE.t60 a_6924_41600.t38 VSS.t269 VSS.t268 nfet_03v3 ad=2.08p pd=8.52u as=2.08p ps=8.52u w=8u l=0.28u
X21 VDD.t237 CLKP_H.t29 a_6924_6400.t22 VDD.t236 pfet_03v3 ad=2.08p pd=8.52u as=2.08p ps=8.52u w=8u l=0.28u
X22 VDD.t275 a_6924_6400.t93 E_SENSE.t57 VDD.t274 pfet_03v3 ad=2.08p pd=8.52u as=2.08p ps=8.52u w=8u l=0.28u
X23 E_SENSE.t63 a_6924_6400.t58 VSS.t285 VSS.t284 nfet_03v3 ad=2.08p pd=8.52u as=2.08p ps=8.52u w=8u l=0.28u
X24 a_6924_6400.t9 CLKP_H.t6 VSS.t253 VSS.t252 nfet_03v3 ad=2.08p pd=8.52u as=2.08p ps=8.52u w=8u l=0.28u
X25 a_6924_41600.t31 CLKN_H.t20 VDD.t201 VDD.t200 pfet_03v3 ad=3.52p pd=16.88u as=2.08p ps=8.52u w=8u l=0.28u
X26 O_SENSE.t9 a_6924_41600.t68 VDD.t37 VDD.t36 pfet_03v3 ad=2.08p pd=8.52u as=2.08p ps=8.52u w=8u l=0.28u
X27 O_SENSE.t51 a_6924_41600.t50 VSS.t141 VSS.t140 nfet_03v3 ad=2.08p pd=8.52u as=2.08p ps=8.52u w=8u l=0.28u
X28 E_CAPTURE_CLKB.t14 a_2700_6400.t14 VSS.t273 VSS.t272 nfet_03v3 ad=2.08p pd=8.52u as=2.08p ps=8.52u w=8u l=0.28u
X29 VDD.t241 CLKP_H.t27 a_6924_6400.t24 VDD.t240 pfet_03v3 ad=2.08p pd=8.52u as=2.08p ps=8.52u w=8u l=0.28u
X30 VDD.t279 a_6924_6400.t91 E_SENSE.t59 VDD.t278 pfet_03v3 ad=2.08p pd=8.52u as=2.08p ps=8.52u w=8u l=0.28u
X31 O_SENSE.t15 a_6924_41600.t80 VDD.t53 VDD.t52 pfet_03v3 ad=2.08p pd=8.52u as=2.08p ps=8.52u w=8u l=0.28u
X32 VDD.t255 a_2700_6400.t23 E_CAPTURE_CLKB.t13 VDD.t254 pfet_03v3 ad=2.08p pd=8.52u as=3.52p ps=16.88u w=8u l=0.28u
X33 VSS.t11 a_6924_41600.t59 O_SENSE.t4 VSS.t10 nfet_03v3 ad=2.08p pd=8.52u as=2.08p ps=8.52u w=8u l=0.28u
X34 a_6924_6400.t21 CLKP_H.t30 VDD.t235 VDD.t234 pfet_03v3 ad=2.08p pd=8.52u as=2.08p ps=8.52u w=8u l=0.28u
X35 E_SENSE.t50 a_6924_6400.t94 VDD.t251 VDD.t250 pfet_03v3 ad=2.08p pd=8.52u as=2.08p ps=8.52u w=8u l=0.28u
X36 a_6924_41600.t7 CLKN_H.t8 VSS.t205 VSS.t204 nfet_03v3 ad=2.08p pd=8.52u as=2.08p ps=8.52u w=8u l=0.28u
X37 a_6924_6400.t23 CLKP_H.t28 VDD.t239 VDD.t238 pfet_03v3 ad=2.08p pd=8.52u as=2.08p ps=8.52u w=8u l=0.28u
X38 E_SENSE.t58 a_6924_6400.t92 VDD.t277 VDD.t276 pfet_03v3 ad=2.08p pd=8.52u as=2.08p ps=8.52u w=8u l=0.28u
X39 a_6924_41600.t25 CLKN_H.t26 VDD.t191 VDD.t190 pfet_03v3 ad=2.08p pd=8.52u as=2.08p ps=8.52u w=8u l=0.28u
X40 O_SENSE.t30 a_6924_41600.t56 VSS.t83 VSS.t82 nfet_03v3 ad=2.08p pd=8.52u as=2.08p ps=8.52u w=8u l=0.28u
X41 O_SENSE.t36 a_6924_41600.t86 VDD.t133 VDD.t132 pfet_03v3 ad=2.08p pd=8.52u as=2.08p ps=8.52u w=8u l=0.28u
X42 a_4812_41600.t1 CLKN_H.t18 VSS.t185 VSS.t184 nfet_03v3 ad=2.08p pd=8.52u as=2.08p ps=8.52u w=8u l=0.28u
X43 VSS.t79 a_6924_6400.t51 E_SENSE.t29 VSS.t78 nfet_03v3 ad=2.08p pd=8.52u as=2.08p ps=8.52u w=8u l=0.28u
X44 E_SENSE.t8 a_6924_6400.t86 VDD.t23 VDD.t22 pfet_03v3 ad=2.08p pd=8.52u as=2.08p ps=8.52u w=8u l=0.28u
X45 VSS.t197 CLKN_H.t5 a_6924_41600.t10 VSS.t196 nfet_03v3 ad=2.08p pd=8.52u as=2.08p ps=8.52u w=8u l=0.28u
X46 E_CAPTURE_CLKB.t5 a_2700_6400.t18 VDD.t73 VDD.t72 pfet_03v3 ad=2.08p pd=8.52u as=2.08p ps=8.52u w=8u l=0.28u
X47 a_4812_41600.t7 CLKN_H.t36 VDD.t175 VDD.t174 pfet_03v3 ad=3.52p pd=16.88u as=2.08p ps=8.52u w=8u l=0.28u
X48 O_CAPTURE_CLK.t10 a_4812_41600.t10 VSS.t99 VSS.t98 nfet_03v3 ad=2.08p pd=8.52u as=2.08p ps=8.52u w=8u l=0.28u
X49 VDD.t197 CLKN_H.t23 a_6924_41600.t28 VDD.t196 pfet_03v3 ad=2.08p pd=8.52u as=2.08p ps=8.52u w=8u l=0.28u
X50 VSS.t217 CLKN_HB.t1 a_2700_41600.t2 VSS.t216 nfet_03v3 ad=2.08p pd=8.52u as=2.08p ps=8.52u w=8u l=0.28u
X51 a_6924_41600.t1 CLKN_H.t14 VSS.t195 VSS.t194 nfet_03v3 ad=2.08p pd=8.52u as=2.08p ps=8.52u w=8u l=0.28u
X52 E_CAPTURE_CLKB.t6 a_2700_6400.t16 VDD.t75 VDD.t74 pfet_03v3 ad=3.52p pd=16.88u as=2.08p ps=8.52u w=8u l=0.28u
X53 a_2700_6400.t1 CLKP_HB.t2 VSS.t173 VSS.t172 nfet_03v3 ad=2.08p pd=8.52u as=2.08p ps=8.52u w=8u l=0.28u
X54 a_6924_41600.t19 CLKN_H.t32 VDD.t165 VDD.t164 pfet_03v3 ad=2.08p pd=8.52u as=2.08p ps=8.52u w=8u l=0.28u
X55 VDD.t159 CLKP_HB.t7 a_2700_6400.t4 VDD.t158 pfet_03v3 ad=2.08p pd=8.52u as=3.52p ps=16.88u w=8u l=0.28u
X56 VDD.t215 CLKP_H.t23 a_6924_6400.t28 VDD.t214 pfet_03v3 ad=2.08p pd=8.52u as=2.08p ps=8.52u w=8u l=0.28u
X57 E_SENSE.t30 a_6924_6400.t52 VSS.t81 VSS.t80 nfet_03v3 ad=2.08p pd=8.52u as=2.08p ps=8.52u w=8u l=0.28u
X58 a_6924_6400.t15 CLKP_H.t0 VSS.t263 VSS.t262 nfet_03v3 ad=3.52p pd=16.88u as=2.08p ps=8.52u w=8u l=0.28u
X59 a_2700_6400.t3 CLKP_HB.t0 VSS.t175 VSS.t174 nfet_03v3 ad=3.52p pd=16.88u as=2.08p ps=8.52u w=8u l=0.28u
X60 VDD.t61 a_6924_6400.t87 E_SENSE.t13 VDD.t60 pfet_03v3 ad=2.08p pd=8.52u as=2.08p ps=8.52u w=8u l=0.28u
X61 VDD.t247 CLKP_H.t21 a_6924_6400.t30 VDD.t246 pfet_03v3 ad=2.08p pd=8.52u as=2.08p ps=8.52u w=8u l=0.28u
X62 E_CAPTURE_CLK.t15 a_4812_6400.t14 VSS.t279 VSS.t278 nfet_03v3 ad=2.08p pd=8.52u as=2.08p ps=8.52u w=8u l=0.28u
X63 VDD.t123 a_6924_6400.t85 E_SENSE.t33 VDD.t122 pfet_03v3 ad=2.08p pd=8.52u as=2.08p ps=8.52u w=8u l=0.28u
X64 VSS.t179 CLKN_H.t11 a_6924_41600.t4 VSS.t178 nfet_03v3 ad=2.08p pd=8.52u as=2.08p ps=8.52u w=8u l=0.28u
X65 VDD.t91 a_2700_6400.t17 E_CAPTURE_CLKB.t7 VDD.t90 pfet_03v3 ad=2.08p pd=8.52u as=2.08p ps=8.52u w=8u l=0.28u
X66 VDD.t119 a_4812_6400.t23 E_CAPTURE_CLK.t9 VDD.t118 pfet_03v3 ad=2.08p pd=8.52u as=3.52p ps=16.88u w=8u l=0.28u
X67 E_SENSE.t12 a_6924_6400.t38 VSS.t25 VSS.t24 nfet_03v3 ad=2.08p pd=8.52u as=2.08p ps=8.52u w=8u l=0.28u
X68 E_CAPTURE_CLK.t7 a_4812_6400.t12 VSS.t59 VSS.t58 nfet_03v3 ad=2.08p pd=8.52u as=2.08p ps=8.52u w=8u l=0.28u
X69 a_4812_6400.t3 CLKP_H.t16 VSS.t235 VSS.t234 nfet_03v3 ad=3.52p pd=16.88u as=2.08p ps=8.52u w=8u l=0.28u
X70 VDD.t185 CLKN_H.t29 a_6924_41600.t22 VDD.t184 pfet_03v3 ad=2.08p pd=8.52u as=2.08p ps=8.52u w=8u l=0.28u
X71 O_SENSE.t16 a_6924_41600.t66 VDD.t55 VDD.t54 pfet_03v3 ad=2.08p pd=8.52u as=2.08p ps=8.52u w=8u l=0.28u
X72 E_SENSE.t5 a_6924_6400.t44 VSS.t5 VSS.t4 nfet_03v3 ad=2.08p pd=8.52u as=2.08p ps=8.52u w=8u l=0.28u
X73 VDD.t103 a_6924_6400.t71 E_SENSE.t25 VDD.t102 pfet_03v3 ad=2.08p pd=8.52u as=2.08p ps=8.52u w=8u l=0.28u
X74 VDD.t17 a_2700_41600.t17 O_CAPTURE_CLKB.t0 VDD.t16 pfet_03v3 ad=2.08p pd=8.52u as=2.08p ps=8.52u w=8u l=0.28u
X75 O_SENSE.t39 a_6924_41600.t78 VDD.t143 VDD.t142 pfet_03v3 ad=2.08p pd=8.52u as=2.08p ps=8.52u w=8u l=0.28u
X76 VSS.t169 CLKP_HB.t1 a_2700_6400.t2 VSS.t168 nfet_03v3 ad=2.08p pd=8.52u as=2.08p ps=8.52u w=8u l=0.28u
X77 VSS.t67 a_6924_41600.t33 O_SENSE.t25 VSS.t66 nfet_03v3 ad=2.08p pd=8.52u as=2.08p ps=8.52u w=8u l=0.28u
X78 VSS.t229 CLKP_H.t19 a_4812_6400.t0 VSS.t228 nfet_03v3 ad=2.08p pd=8.52u as=3.52p ps=16.88u w=8u l=0.28u
X79 VDD.t87 a_4812_41600.t21 O_CAPTURE_CLK.t5 VDD.t86 pfet_03v3 ad=2.08p pd=8.52u as=2.08p ps=8.52u w=8u l=0.28u
X80 VSS.t157 a_6924_41600.t45 O_SENSE.t54 VSS.t156 nfet_03v3 ad=2.08p pd=8.52u as=2.08p ps=8.52u w=8u l=0.28u
X81 VSS.t13 a_4812_6400.t13 E_CAPTURE_CLK.t0 VSS.t12 nfet_03v3 ad=2.08p pd=8.52u as=2.08p ps=8.52u w=8u l=0.28u
X82 VSS.t233 CLKP_H.t17 a_4812_6400.t2 VSS.t232 nfet_03v3 ad=2.08p pd=8.52u as=2.08p ps=8.52u w=8u l=0.28u
X83 VDD.t117 a_6924_41600.t75 O_SENSE.t32 VDD.t116 pfet_03v3 ad=2.08p pd=8.52u as=2.08p ps=8.52u w=8u l=0.28u
X84 a_4812_6400.t5 CLKP_H.t38 VDD.t219 VDD.t218 pfet_03v3 ad=2.08p pd=8.52u as=2.08p ps=8.52u w=8u l=0.28u
X85 VSS.t137 a_6924_6400.t45 E_SENSE.t46 VSS.t136 nfet_03v3 ad=2.08p pd=8.52u as=2.08p ps=8.52u w=8u l=0.28u
X86 E_SENSE.t10 a_6924_6400.t72 VDD.t27 VDD.t26 pfet_03v3 ad=2.08p pd=8.52u as=2.08p ps=8.52u w=8u l=0.28u
X87 E_SENSE.t36 a_6924_6400.t80 VDD.t125 VDD.t124 pfet_03v3 ad=2.08p pd=8.52u as=2.08p ps=8.52u w=8u l=0.28u
X88 a_2700_41600.t5 CLKN_HB.t6 VDD.t205 VDD.t204 pfet_03v3 ad=2.08p pd=8.52u as=2.08p ps=8.52u w=8u l=0.28u
X89 E_SENSE.t37 a_6924_6400.t78 VDD.t129 VDD.t128 pfet_03v3 ad=2.08p pd=8.52u as=2.08p ps=8.52u w=8u l=0.28u
X90 VDD.t47 a_2700_41600.t23 O_CAPTURE_CLKB.t4 VDD.t46 pfet_03v3 ad=2.08p pd=8.52u as=3.52p ps=16.88u w=8u l=0.28u
X91 O_SENSE.t50 a_6924_41600.t42 VSS.t131 VSS.t130 nfet_03v3 ad=2.08p pd=8.52u as=2.08p ps=8.52u w=8u l=0.28u
X92 O_CAPTURE_CLKB.t9 a_2700_41600.t14 VSS.t45 VSS.t44 nfet_03v3 ad=2.08p pd=8.52u as=2.08p ps=8.52u w=8u l=0.28u
X93 VSS.t161 a_6924_41600.t39 O_SENSE.t56 VSS.t160 nfet_03v3 ad=2.08p pd=8.52u as=2.08p ps=8.52u w=8u l=0.28u
X94 VDD.t199 CLKN_H.t21 a_6924_41600.t30 VDD.t198 pfet_03v3 ad=2.08p pd=8.52u as=2.08p ps=8.52u w=8u l=0.28u
X95 O_SENSE.t5 a_6924_41600.t94 VDD.t29 VDD.t28 pfet_03v3 ad=2.08p pd=8.52u as=2.08p ps=8.52u w=8u l=0.28u
X96 VSS.t155 a_6924_41600.t51 O_SENSE.t53 VSS.t154 nfet_03v3 ad=2.08p pd=8.52u as=2.08p ps=8.52u w=8u l=0.28u
X97 O_CAPTURE_CLKB.t7 a_2700_41600.t20 VDD.t59 VDD.t58 pfet_03v3 ad=2.08p pd=8.52u as=2.08p ps=8.52u w=8u l=0.28u
X98 E_CAPTURE_CLK.t10 a_4812_6400.t8 VSS.t113 VSS.t112 nfet_03v3 ad=3.52p pd=16.88u as=2.08p ps=8.52u w=8u l=0.28u
X99 a_6924_6400.t1 CLKP_H.t14 VSS.t227 VSS.t226 nfet_03v3 ad=2.08p pd=8.52u as=2.08p ps=8.52u w=8u l=0.28u
X100 VDD.t261 a_6924_6400.t79 E_SENSE.t52 VDD.t260 pfet_03v3 ad=2.08p pd=8.52u as=2.08p ps=8.52u w=8u l=0.28u
X101 VDD.t135 a_6924_41600.t81 O_SENSE.t37 VDD.t134 pfet_03v3 ad=2.08p pd=8.52u as=2.08p ps=8.52u w=8u l=0.28u
X102 a_6924_41600.t15 CLKN_H.t0 VSS.t215 VSS.t214 nfet_03v3 ad=3.52p pd=16.88u as=2.08p ps=8.52u w=8u l=0.28u
X103 E_SENSE.t24 a_6924_6400.t32 VSS.t57 VSS.t56 nfet_03v3 ad=3.52p pd=16.88u as=2.08p ps=8.52u w=8u l=0.28u
X104 O_SENSE.t13 a_6924_41600.t36 VSS.t31 VSS.t30 nfet_03v3 ad=2.08p pd=8.52u as=2.08p ps=8.52u w=8u l=0.28u
X105 VDD.t67 a_4812_6400.t17 E_CAPTURE_CLK.t4 VDD.t66 pfet_03v3 ad=2.08p pd=8.52u as=2.08p ps=8.52u w=8u l=0.28u
X106 O_SENSE.t48 a_6924_41600.t48 VSS.t127 VSS.t126 nfet_03v3 ad=2.08p pd=8.52u as=2.08p ps=8.52u w=8u l=0.28u
X107 VDD.t283 a_6924_6400.t65 E_SENSE.t61 VDD.t282 pfet_03v3 ad=2.08p pd=8.52u as=2.08p ps=8.52u w=8u l=0.28u
X108 VDD.t189 CLKN_H.t27 a_6924_41600.t24 VDD.t188 pfet_03v3 ad=2.08p pd=8.52u as=2.08p ps=8.52u w=8u l=0.28u
X109 VSS.t237 CLKP_H.t15 a_6924_6400.t0 VSS.t236 nfet_03v3 ad=2.08p pd=8.52u as=3.52p ps=16.88u w=8u l=0.28u
X110 VSS.t265 a_6924_6400.t61 E_SENSE.t51 VSS.t264 nfet_03v3 ad=2.08p pd=8.52u as=2.08p ps=8.52u w=8u l=0.28u
X111 VSS.t247 CLKP_H.t9 a_6924_6400.t6 VSS.t246 nfet_03v3 ad=2.08p pd=8.52u as=2.08p ps=8.52u w=8u l=0.28u
X112 E_SENSE.t60 a_6924_6400.t74 VDD.t281 VDD.t280 pfet_03v3 ad=2.08p pd=8.52u as=2.08p ps=8.52u w=8u l=0.28u
X113 a_6924_41600.t9 CLKN_H.t6 VSS.t209 VSS.t208 nfet_03v3 ad=2.08p pd=8.52u as=2.08p ps=8.52u w=8u l=0.28u
X114 VSS.t51 a_6924_6400.t59 E_SENSE.t21 VSS.t50 nfet_03v3 ad=2.08p pd=8.52u as=2.08p ps=8.52u w=8u l=0.28u
X115 VSS.t251 CLKP_H.t7 a_6924_6400.t8 VSS.t250 nfet_03v3 ad=2.08p pd=8.52u as=2.08p ps=8.52u w=8u l=0.28u
X116 a_6924_41600.t27 CLKN_H.t24 VDD.t195 VDD.t194 pfet_03v3 ad=2.08p pd=8.52u as=2.08p ps=8.52u w=8u l=0.28u
X117 VSS.t21 a_2700_6400.t15 E_CAPTURE_CLKB.t1 VSS.t20 nfet_03v3 ad=2.08p pd=8.52u as=3.52p ps=16.88u w=8u l=0.28u
X118 O_SENSE.t33 a_6924_41600.t54 VSS.t95 VSS.t94 nfet_03v3 ad=2.08p pd=8.52u as=2.08p ps=8.52u w=8u l=0.28u
X119 a_2700_41600.t7 CLKN_HB.t4 VDD.t209 VDD.t208 pfet_03v3 ad=3.52p pd=16.88u as=2.08p ps=8.52u w=8u l=0.28u
X120 a_4812_41600.t3 CLKN_H.t16 VSS.t191 VSS.t190 nfet_03v3 ad=3.52p pd=16.88u as=2.08p ps=8.52u w=8u l=0.28u
X121 VSS.t193 CLKN_H.t3 a_6924_41600.t12 VSS.t192 nfet_03v3 ad=2.08p pd=8.52u as=2.08p ps=8.52u w=8u l=0.28u
X122 E_SENSE.t42 a_6924_6400.t62 VSS.t111 VSS.t110 nfet_03v3 ad=2.08p pd=8.52u as=2.08p ps=8.52u w=8u l=0.28u
X123 a_6924_6400.t5 CLKP_H.t10 VSS.t245 VSS.t244 nfet_03v3 ad=2.08p pd=8.52u as=2.08p ps=8.52u w=8u l=0.28u
X124 VDD.t233 CLKP_H.t31 a_6924_6400.t20 VDD.t232 pfet_03v3 ad=2.08p pd=8.52u as=2.08p ps=8.52u w=8u l=0.28u
X125 VDD.t273 a_6924_6400.t95 E_SENSE.t56 VDD.t272 pfet_03v3 ad=2.08p pd=8.52u as=3.52p ps=16.88u w=8u l=0.28u
X126 E_SENSE.t3 a_6924_6400.t60 VSS.t1 VSS.t0 nfet_03v3 ad=2.08p pd=8.52u as=2.08p ps=8.52u w=8u l=0.28u
X127 a_6924_6400.t7 CLKP_H.t8 VSS.t249 VSS.t248 nfet_03v3 ad=2.08p pd=8.52u as=2.08p ps=8.52u w=8u l=0.28u
X128 a_6924_41600.t3 CLKN_H.t12 VSS.t187 VSS.t186 nfet_03v3 ad=2.08p pd=8.52u as=2.08p ps=8.52u w=8u l=0.28u
X129 O_SENSE.t14 a_6924_41600.t92 VDD.t51 VDD.t50 pfet_03v3 ad=2.08p pd=8.52u as=2.08p ps=8.52u w=8u l=0.28u
X130 E_SENSE.t55 a_6924_6400.t54 VSS.t277 VSS.t276 nfet_03v3 ad=2.08p pd=8.52u as=2.08p ps=8.52u w=8u l=0.28u
X131 E_CAPTURE_CLKB.t11 a_2700_6400.t10 VSS.t167 VSS.t166 nfet_03v3 ad=2.08p pd=8.52u as=2.08p ps=8.52u w=8u l=0.28u
X132 VSS.t203 CLKN_H.t9 a_6924_41600.t6 VSS.t202 nfet_03v3 ad=2.08p pd=8.52u as=2.08p ps=8.52u w=8u l=0.28u
X133 O_SENSE.t26 a_6924_41600.t34 VSS.t69 VSS.t68 nfet_03v3 ad=2.08p pd=8.52u as=2.08p ps=8.52u w=8u l=0.28u
X134 VDD.t115 a_2700_6400.t19 E_CAPTURE_CLKB.t8 VDD.t114 pfet_03v3 ad=2.08p pd=8.52u as=2.08p ps=8.52u w=8u l=0.28u
X135 E_CAPTURE_CLKB.t0 a_2700_6400.t8 VSS.t19 VSS.t18 nfet_03v3 ad=3.52p pd=16.88u as=2.08p ps=8.52u w=8u l=0.28u
X136 VSS.t37 a_2700_41600.t9 O_CAPTURE_CLKB.t5 VSS.t36 nfet_03v3 ad=2.08p pd=8.52u as=2.08p ps=8.52u w=8u l=0.28u
X137 VDD.t95 a_6924_41600.t89 O_SENSE.t19 VDD.t94 pfet_03v3 ad=2.08p pd=8.52u as=2.08p ps=8.52u w=8u l=0.28u
X138 O_SENSE.t55 a_6924_41600.t46 VSS.t159 VSS.t158 nfet_03v3 ad=2.08p pd=8.52u as=2.08p ps=8.52u w=8u l=0.28u
X139 VSS.t75 a_6924_6400.t55 E_SENSE.t27 VSS.t74 nfet_03v3 ad=2.08p pd=8.52u as=2.08p ps=8.52u w=8u l=0.28u
X140 VSS.t257 CLKP_H.t3 a_6924_6400.t12 VSS.t256 nfet_03v3 ad=2.08p pd=8.52u as=2.08p ps=8.52u w=8u l=0.28u
X141 O_SENSE.t20 a_6924_41600.t76 VDD.t97 VDD.t96 pfet_03v3 ad=2.08p pd=8.52u as=2.08p ps=8.52u w=8u l=0.28u
X142 VSS.t171 CLKP_HB.t3 a_2700_6400.t0 VSS.t170 nfet_03v3 ad=2.08p pd=8.52u as=3.52p ps=16.88u w=8u l=0.28u
X143 VDD.t207 CLKN_HB.t7 a_2700_41600.t4 VDD.t206 pfet_03v3 ad=2.08p pd=8.52u as=3.52p ps=16.88u w=8u l=0.28u
X144 VSS.t87 a_4812_41600.t13 O_CAPTURE_CLK.t7 VSS.t86 nfet_03v3 ad=2.08p pd=8.52u as=2.08p ps=8.52u w=8u l=0.28u
X145 a_6924_6400.t27 CLKP_H.t24 VDD.t213 VDD.t212 pfet_03v3 ad=2.08p pd=8.52u as=2.08p ps=8.52u w=8u l=0.28u
X146 E_SENSE.t18 a_6924_6400.t88 VDD.t77 VDD.t76 pfet_03v3 ad=2.08p pd=8.52u as=2.08p ps=8.52u w=8u l=0.28u
X147 VSS.t275 a_6924_6400.t53 E_SENSE.t54 VSS.t274 nfet_03v3 ad=2.08p pd=8.52u as=2.08p ps=8.52u w=8u l=0.28u
X148 VSS.t261 CLKP_H.t1 a_6924_6400.t14 VSS.t260 nfet_03v3 ad=2.08p pd=8.52u as=2.08p ps=8.52u w=8u l=0.28u
X149 VDD.t285 a_4812_41600.t19 O_CAPTURE_CLK.t13 VDD.t284 pfet_03v3 ad=2.08p pd=8.52u as=2.08p ps=8.52u w=8u l=0.28u
X150 a_6924_6400.t29 CLKP_H.t22 VDD.t245 VDD.t244 pfet_03v3 ad=2.08p pd=8.52u as=2.08p ps=8.52u w=8u l=0.28u
X151 E_CAPTURE_CLKB.t2 a_2700_6400.t20 VDD.t21 VDD.t20 pfet_03v3 ad=2.08p pd=8.52u as=2.08p ps=8.52u w=8u l=0.28u
X152 VSS.t165 a_2700_6400.t9 E_CAPTURE_CLKB.t10 VSS.t164 nfet_03v3 ad=2.08p pd=8.52u as=2.08p ps=8.52u w=8u l=0.28u
X153 VDD.t177 CLKN_H.t35 a_6924_41600.t16 VDD.t176 pfet_03v3 ad=2.08p pd=8.52u as=3.52p ps=16.88u w=8u l=0.28u
X154 a_2700_41600.t1 CLKN_HB.t2 VSS.t219 VSS.t218 nfet_03v3 ad=2.08p pd=8.52u as=2.08p ps=8.52u w=8u l=0.28u
X155 VSS.t119 a_6924_41600.t43 O_SENSE.t44 VSS.t118 nfet_03v3 ad=2.08p pd=8.52u as=2.08p ps=8.52u w=8u l=0.28u
X156 VSS.t33 a_4812_6400.t15 E_CAPTURE_CLK.t2 VSS.t32 nfet_03v3 ad=2.08p pd=8.52u as=3.52p ps=16.88u w=8u l=0.28u
X157 VSS.t101 a_2700_41600.t15 O_CAPTURE_CLKB.t13 VSS.t100 nfet_03v3 ad=2.08p pd=8.52u as=3.52p ps=16.88u w=8u l=0.28u
X158 VSS.t47 a_6924_6400.t39 E_SENSE.t16 VSS.t46 nfet_03v3 ad=2.08p pd=8.52u as=2.08p ps=8.52u w=8u l=0.28u
X159 a_6924_41600.t29 CLKN_H.t22 VDD.t193 VDD.t192 pfet_03v3 ad=2.08p pd=8.52u as=2.08p ps=8.52u w=8u l=0.28u
X160 VDD.t7 a_6924_41600.t95 O_SENSE.t0 VDD.t6 pfet_03v3 ad=2.08p pd=8.52u as=3.52p ps=16.88u w=8u l=0.28u
X161 VDD.t111 a_2700_41600.t21 O_CAPTURE_CLKB.t10 VDD.t110 pfet_03v3 ad=2.08p pd=8.52u as=2.08p ps=8.52u w=8u l=0.28u
X162 O_CAPTURE_CLK.t2 a_4812_41600.t16 VDD.t45 VDD.t44 pfet_03v3 ad=3.52p pd=16.88u as=2.08p ps=8.52u w=8u l=0.28u
X163 VDD.t221 CLKP_H.t25 a_6924_6400.t26 VDD.t220 pfet_03v3 ad=2.08p pd=8.52u as=2.08p ps=8.52u w=8u l=0.28u
X164 VDD.t1 a_6924_6400.t89 E_SENSE.t0 VDD.t0 pfet_03v3 ad=2.08p pd=8.52u as=2.08p ps=8.52u w=8u l=0.28u
X165 VSS.t213 CLKN_H.t1 a_6924_41600.t14 VSS.t212 nfet_03v3 ad=2.08p pd=8.52u as=2.08p ps=8.52u w=8u l=0.28u
X166 O_CAPTURE_CLKB.t3 a_2700_41600.t12 VSS.t17 VSS.t16 nfet_03v3 ad=2.08p pd=8.52u as=2.08p ps=8.52u w=8u l=0.28u
X167 O_SENSE.t35 a_6924_41600.t62 VSS.t109 VSS.t108 nfet_03v3 ad=2.08p pd=8.52u as=2.08p ps=8.52u w=8u l=0.28u
X168 E_SENSE.t45 a_6924_6400.t48 VSS.t135 VSS.t134 nfet_03v3 ad=2.08p pd=8.52u as=2.08p ps=8.52u w=8u l=0.28u
X169 VSS.t117 a_6924_41600.t49 O_SENSE.t43 VSS.t116 nfet_03v3 ad=2.08p pd=8.52u as=2.08p ps=8.52u w=8u l=0.28u
X170 E_SENSE.t17 a_6924_6400.t40 VSS.t49 VSS.t48 nfet_03v3 ad=2.08p pd=8.52u as=2.08p ps=8.52u w=8u l=0.28u
X171 a_4812_6400.t1 CLKP_H.t18 VSS.t231 VSS.t230 nfet_03v3 ad=2.08p pd=8.52u as=2.08p ps=8.52u w=8u l=0.28u
X172 O_CAPTURE_CLKB.t1 a_2700_41600.t18 VDD.t19 VDD.t18 pfet_03v3 ad=2.08p pd=8.52u as=2.08p ps=8.52u w=8u l=0.28u
X173 E_SENSE.t47 a_6924_6400.t46 VSS.t139 VSS.t138 nfet_03v3 ad=2.08p pd=8.52u as=2.08p ps=8.52u w=8u l=0.28u
X174 VDD.t65 a_6924_6400.t73 E_SENSE.t15 VDD.t64 pfet_03v3 ad=2.08p pd=8.52u as=2.08p ps=8.52u w=8u l=0.28u
X175 VDD.t25 a_6924_6400.t81 E_SENSE.t9 VDD.t24 pfet_03v3 ad=2.08p pd=8.52u as=2.08p ps=8.52u w=8u l=0.28u
X176 O_CAPTURE_CLK.t6 a_4812_41600.t22 VDD.t89 VDD.t88 pfet_03v3 ad=2.08p pd=8.52u as=2.08p ps=8.52u w=8u l=0.28u
X177 VSS.t207 CLKN_H.t7 a_6924_41600.t8 VSS.t206 nfet_03v3 ad=2.08p pd=8.52u as=2.08p ps=8.52u w=8u l=0.28u
X178 VSS.t133 a_6924_6400.t47 E_SENSE.t44 VSS.t132 nfet_03v3 ad=2.08p pd=8.52u as=2.08p ps=8.52u w=8u l=0.28u
X179 E_SENSE.t14 a_6924_6400.t82 VDD.t63 VDD.t62 pfet_03v3 ad=2.08p pd=8.52u as=2.08p ps=8.52u w=8u l=0.28u
X180 VDD.t167 CLKN_H.t39 a_4812_41600.t4 VDD.t166 pfet_03v3 ad=2.08p pd=8.52u as=3.52p ps=16.88u w=8u l=0.28u
X181 VSS.t271 a_4812_6400.t9 E_CAPTURE_CLK.t13 VSS.t270 nfet_03v3 ad=2.08p pd=8.52u as=2.08p ps=8.52u w=8u l=0.28u
X182 VSS.t7 a_6924_6400.t33 E_SENSE.t6 VSS.t6 nfet_03v3 ad=2.08p pd=8.52u as=2.08p ps=8.52u w=8u l=0.28u
X183 E_SENSE.t53 a_6924_6400.t68 VDD.t263 VDD.t262 pfet_03v3 ad=2.08p pd=8.52u as=2.08p ps=8.52u w=8u l=0.28u
X184 O_SENSE.t8 a_6924_41600.t72 VDD.t35 VDD.t34 pfet_03v3 ad=2.08p pd=8.52u as=2.08p ps=8.52u w=8u l=0.28u
X185 a_6924_41600.t11 CLKN_H.t4 VSS.t177 VSS.t176 nfet_03v3 ad=2.08p pd=8.52u as=2.08p ps=8.52u w=8u l=0.28u
X186 E_CAPTURE_CLK.t3 a_4812_6400.t18 VDD.t43 VDD.t42 pfet_03v3 ad=2.08p pd=8.52u as=2.08p ps=8.52u w=8u l=0.28u
X187 O_SENSE.t29 a_6924_41600.t84 VDD.t109 VDD.t108 pfet_03v3 ad=2.08p pd=8.52u as=2.08p ps=8.52u w=8u l=0.28u
X188 a_2700_41600.t3 CLKN_HB.t0 VSS.t223 VSS.t222 nfet_03v3 ad=3.52p pd=16.88u as=2.08p ps=8.52u w=8u l=0.28u
X189 E_SENSE.t40 a_6924_6400.t66 VDD.t139 VDD.t138 pfet_03v3 ad=2.08p pd=8.52u as=2.08p ps=8.52u w=8u l=0.28u
X190 VDD.t153 a_6924_41600.t69 O_SENSE.t52 VDD.t152 pfet_03v3 ad=2.08p pd=8.52u as=2.08p ps=8.52u w=8u l=0.28u
X191 VDD.t41 a_4812_6400.t19 E_CAPTURE_CLK.t1 VDD.t40 pfet_03v3 ad=2.08p pd=8.52u as=2.08p ps=8.52u w=8u l=0.28u
X192 E_SENSE.t23 a_6924_6400.t42 VSS.t55 VSS.t54 nfet_03v3 ad=2.08p pd=8.52u as=2.08p ps=8.52u w=8u l=0.28u
X193 VDD.t145 a_6924_6400.t69 E_SENSE.t41 VDD.t144 pfet_03v3 ad=2.08p pd=8.52u as=2.08p ps=8.52u w=8u l=0.28u
X194 VDD.t81 a_6924_6400.t75 E_SENSE.t20 VDD.t80 pfet_03v3 ad=2.08p pd=8.52u as=2.08p ps=8.52u w=8u l=0.28u
X195 O_SENSE.t17 a_6924_41600.t60 VSS.t41 VSS.t40 nfet_03v3 ad=2.08p pd=8.52u as=2.08p ps=8.52u w=8u l=0.28u
X196 VDD.t131 a_6924_6400.t67 E_SENSE.t38 VDD.t130 pfet_03v3 ad=2.08p pd=8.52u as=2.08p ps=8.52u w=8u l=0.28u
X197 O_CAPTURE_CLKB.t14 a_2700_41600.t16 VDD.t121 VDD.t120 pfet_03v3 ad=3.52p pd=16.88u as=2.08p ps=8.52u w=8u l=0.28u
X198 O_SENSE.t6 a_6924_41600.t90 VDD.t31 VDD.t30 pfet_03v3 ad=2.08p pd=8.52u as=2.08p ps=8.52u w=8u l=0.28u
X199 VSS.t65 a_6924_41600.t57 O_SENSE.t24 VSS.t64 nfet_03v3 ad=2.08p pd=8.52u as=2.08p ps=8.52u w=8u l=0.28u
X200 VSS.t93 a_6924_6400.t63 E_SENSE.t32 VSS.t92 nfet_03v3 ad=2.08p pd=8.52u as=3.52p ps=16.88u w=8u l=0.28u
X201 VSS.t243 CLKP_H.t11 a_6924_6400.t4 VSS.t242 nfet_03v3 ad=2.08p pd=8.52u as=2.08p ps=8.52u w=8u l=0.28u
X202 O_CAPTURE_CLK.t14 a_4812_41600.t20 VDD.t287 VDD.t286 pfet_03v3 ad=2.08p pd=8.52u as=2.08p ps=8.52u w=8u l=0.28u
X203 O_SENSE.t45 a_6924_41600.t44 VSS.t121 VSS.t120 nfet_03v3 ad=2.08p pd=8.52u as=2.08p ps=8.52u w=8u l=0.28u
X204 a_6924_6400.t19 CLKP_H.t32 VDD.t211 VDD.t210 pfet_03v3 ad=2.08p pd=8.52u as=2.08p ps=8.52u w=8u l=0.28u
X205 VDD.t265 a_6924_41600.t87 O_SENSE.t61 VDD.t264 pfet_03v3 ad=2.08p pd=8.52u as=2.08p ps=8.52u w=8u l=0.28u
X206 VSS.t221 CLKN_HB.t3 a_2700_41600.t0 VSS.t220 nfet_03v3 ad=2.08p pd=8.52u as=3.52p ps=16.88u w=8u l=0.28u
X207 VDD.t173 CLKN_H.t37 a_4812_41600.t6 VDD.t172 pfet_03v3 ad=2.08p pd=8.52u as=2.08p ps=8.52u w=8u l=0.28u
X208 VSS.t143 a_4812_41600.t11 O_CAPTURE_CLK.t11 VSS.t142 nfet_03v3 ad=2.08p pd=8.52u as=2.08p ps=8.52u w=8u l=0.28u
X209 VDD.t69 a_4812_41600.t17 O_CAPTURE_CLK.t3 VDD.t68 pfet_03v3 ad=2.08p pd=8.52u as=2.08p ps=8.52u w=8u l=0.28u
X210 VSS.t199 CLKN_H.t15 a_6924_41600.t0 VSS.t198 nfet_03v3 ad=2.08p pd=8.52u as=3.52p ps=16.88u w=8u l=0.28u
X211 VSS.t39 a_2700_6400.t11 E_CAPTURE_CLKB.t3 VSS.t38 nfet_03v3 ad=2.08p pd=8.52u as=2.08p ps=8.52u w=8u l=0.28u
X212 VDD.t179 CLKN_H.t33 a_6924_41600.t18 VDD.t178 pfet_03v3 ad=2.08p pd=8.52u as=2.08p ps=8.52u w=8u l=0.28u
X213 a_6924_41600.t13 CLKN_H.t2 VSS.t211 VSS.t210 nfet_03v3 ad=2.08p pd=8.52u as=2.08p ps=8.52u w=8u l=0.28u
X214 VSS.t63 a_6924_41600.t63 O_SENSE.t23 VSS.t62 nfet_03v3 ad=2.08p pd=8.52u as=3.52p ps=16.88u w=8u l=0.28u
X215 VDD.t231 CLKP_H.t33 a_6924_6400.t18 VDD.t230 pfet_03v3 ad=2.08p pd=8.52u as=2.08p ps=8.52u w=8u l=0.28u
X216 VSS.t43 a_2700_41600.t13 O_CAPTURE_CLKB.t8 VSS.t42 nfet_03v3 ad=2.08p pd=8.52u as=2.08p ps=8.52u w=8u l=0.28u
X217 VDD.t93 a_6924_41600.t93 O_SENSE.t18 VDD.t92 pfet_03v3 ad=2.08p pd=8.52u as=2.08p ps=8.52u w=8u l=0.28u
X218 O_CAPTURE_CLK.t15 a_4812_41600.t8 VSS.t287 VSS.t286 nfet_03v3 ad=3.52p pd=16.88u as=2.08p ps=8.52u w=8u l=0.28u
X219 E_SENSE.t28 a_6924_6400.t56 VSS.t77 VSS.t76 nfet_03v3 ad=2.08p pd=8.52u as=2.08p ps=8.52u w=8u l=0.28u
X220 VDD.t57 a_2700_41600.t19 O_CAPTURE_CLKB.t6 VDD.t56 pfet_03v3 ad=2.08p pd=8.52u as=2.08p ps=8.52u w=8u l=0.28u
X221 a_6924_6400.t11 CLKP_H.t4 VSS.t255 VSS.t254 nfet_03v3 ad=2.08p pd=8.52u as=2.08p ps=8.52u w=8u l=0.28u
X222 a_6924_41600.t21 CLKN_H.t30 VDD.t183 VDD.t182 pfet_03v3 ad=2.08p pd=8.52u as=2.08p ps=8.52u w=8u l=0.28u
X223 VDD.t101 a_6924_41600.t67 O_SENSE.t22 VDD.t100 pfet_03v3 ad=2.08p pd=8.52u as=2.08p ps=8.52u w=8u l=0.28u
X224 E_CAPTURE_CLKB.t9 a_2700_6400.t12 VSS.t103 VSS.t102 nfet_03v3 ad=2.08p pd=8.52u as=2.08p ps=8.52u w=8u l=0.28u
X225 a_6924_6400.t13 CLKP_H.t2 VSS.t259 VSS.t258 nfet_03v3 ad=2.08p pd=8.52u as=2.08p ps=8.52u w=8u l=0.28u
X226 O_CAPTURE_CLKB.t15 a_2700_41600.t10 VSS.t153 VSS.t152 nfet_03v3 ad=2.08p pd=8.52u as=2.08p ps=8.52u w=8u l=0.28u
X227 VDD.t49 a_2700_6400.t21 E_CAPTURE_CLKB.t4 VDD.t48 pfet_03v3 ad=2.08p pd=8.52u as=2.08p ps=8.52u w=8u l=0.28u
X228 VDD.t15 a_4812_41600.t23 O_CAPTURE_CLK.t0 VDD.t14 pfet_03v3 ad=2.08p pd=8.52u as=3.52p ps=16.88u w=8u l=0.28u
X229 VDD.t11 a_6924_41600.t79 O_SENSE.t2 VDD.t10 pfet_03v3 ad=2.08p pd=8.52u as=2.08p ps=8.52u w=8u l=0.28u
X230 VSS.t283 a_6924_6400.t57 E_SENSE.t62 VSS.t282 nfet_03v3 ad=2.08p pd=8.52u as=2.08p ps=8.52u w=8u l=0.28u
X231 VSS.t225 CLKP_H.t5 a_6924_6400.t10 VSS.t224 nfet_03v3 ad=2.08p pd=8.52u as=2.08p ps=8.52u w=8u l=0.28u
X232 O_SENSE.t10 a_6924_41600.t64 VDD.t39 VDD.t38 pfet_03v3 ad=3.52p pd=16.88u as=2.08p ps=8.52u w=8u l=0.28u
X233 O_CAPTURE_CLK.t8 a_4812_41600.t14 VSS.t89 VSS.t88 nfet_03v3 ad=2.08p pd=8.52u as=2.08p ps=8.52u w=8u l=0.28u
X234 a_6924_6400.t25 CLKP_H.t26 VDD.t243 VDD.t242 pfet_03v3 ad=2.08p pd=8.52u as=2.08p ps=8.52u w=8u l=0.28u
X235 E_SENSE.t43 a_6924_6400.t90 VDD.t151 VDD.t150 pfet_03v3 ad=2.08p pd=8.52u as=2.08p ps=8.52u w=8u l=0.28u
X236 VSS.t183 CLKN_H.t19 a_4812_41600.t0 VSS.t182 nfet_03v3 ad=2.08p pd=8.52u as=3.52p ps=16.88u w=8u l=0.28u
X237 E_CAPTURE_CLKB.t12 a_2700_6400.t22 VDD.t253 VDD.t252 pfet_03v3 ad=2.08p pd=8.52u as=2.08p ps=8.52u w=8u l=0.28u
X238 VDD.t257 a_6924_41600.t73 O_SENSE.t58 VDD.t256 pfet_03v3 ad=2.08p pd=8.52u as=2.08p ps=8.52u w=8u l=0.28u
X239 VSS.t147 a_6924_6400.t49 E_SENSE.t48 VSS.t146 nfet_03v3 ad=2.08p pd=8.52u as=2.08p ps=8.52u w=8u l=0.28u
X240 VDD.t141 a_6924_41600.t85 O_SENSE.t38 VDD.t140 pfet_03v3 ad=2.08p pd=8.52u as=2.08p ps=8.52u w=8u l=0.28u
X241 VSS.t53 a_6924_6400.t41 E_SENSE.t22 VSS.t52 nfet_03v3 ad=2.08p pd=8.52u as=2.08p ps=8.52u w=8u l=0.28u
X242 O_SENSE.t57 a_6924_41600.t40 VSS.t163 VSS.t162 nfet_03v3 ad=2.08p pd=8.52u as=2.08p ps=8.52u w=8u l=0.28u
X243 O_SENSE.t46 a_6924_41600.t52 VSS.t123 VSS.t122 nfet_03v3 ad=2.08p pd=8.52u as=2.08p ps=8.52u w=8u l=0.28u
X244 O_SENSE.t63 a_6924_41600.t70 VDD.t269 VDD.t268 pfet_03v3 ad=2.08p pd=8.52u as=2.08p ps=8.52u w=8u l=0.28u
X245 O_SENSE.t62 a_6924_41600.t82 VDD.t267 VDD.t266 pfet_03v3 ad=2.08p pd=8.52u as=2.08p ps=8.52u w=8u l=0.28u
X246 E_SENSE.t49 a_6924_6400.t50 VSS.t149 VSS.t148 nfet_03v3 ad=2.08p pd=8.52u as=2.08p ps=8.52u w=8u l=0.28u
X247 VSS.t267 a_6924_41600.t37 O_SENSE.t59 VSS.t266 nfet_03v3 ad=2.08p pd=8.52u as=2.08p ps=8.52u w=8u l=0.28u
X248 VDD.t79 a_6924_6400.t83 E_SENSE.t19 VDD.t78 pfet_03v3 ad=2.08p pd=8.52u as=2.08p ps=8.52u w=8u l=0.28u
X249 VDD.t9 a_6924_41600.t91 O_SENSE.t1 VDD.t8 pfet_03v3 ad=2.08p pd=8.52u as=2.08p ps=8.52u w=8u l=0.28u
X250 E_SENSE.t35 a_6924_6400.t36 VSS.t107 VSS.t106 nfet_03v3 ad=2.08p pd=8.52u as=2.08p ps=8.52u w=8u l=0.28u
X251 E_CAPTURE_CLK.t11 a_4812_6400.t10 VSS.t151 VSS.t150 nfet_03v3 ad=2.08p pd=8.52u as=2.08p ps=8.52u w=8u l=0.28u
X252 E_SENSE.t7 a_6924_6400.t34 VSS.t9 VSS.t8 nfet_03v3 ad=2.08p pd=8.52u as=2.08p ps=8.52u w=8u l=0.28u
X253 a_6924_41600.t23 CLKN_H.t28 VDD.t187 VDD.t186 pfet_03v3 ad=2.08p pd=8.52u as=2.08p ps=8.52u w=8u l=0.28u
X254 O_SENSE.t11 a_6924_41600.t58 VSS.t27 VSS.t26 nfet_03v3 ad=2.08p pd=8.52u as=2.08p ps=8.52u w=8u l=0.28u
X255 a_2700_6400.t5 CLKP_HB.t6 VDD.t157 VDD.t156 pfet_03v3 ad=2.08p pd=8.52u as=2.08p ps=8.52u w=8u l=0.28u
X256 O_CAPTURE_CLKB.t12 a_2700_41600.t8 VSS.t91 VSS.t90 nfet_03v3 ad=3.52p pd=16.88u as=2.08p ps=8.52u w=8u l=0.28u
X257 a_2700_6400.t7 CLKP_HB.t4 VDD.t155 VDD.t154 pfet_03v3 ad=3.52p pd=16.88u as=2.08p ps=8.52u w=8u l=0.28u
X258 a_6924_6400.t31 CLKP_H.t20 VDD.t249 VDD.t248 pfet_03v3 ad=3.52p pd=16.88u as=2.08p ps=8.52u w=8u l=0.28u
X259 E_SENSE.t1 a_6924_6400.t84 VDD.t3 VDD.t2 pfet_03v3 ad=2.08p pd=8.52u as=2.08p ps=8.52u w=8u l=0.28u
X260 O_SENSE.t34 a_6924_41600.t88 VDD.t127 VDD.t126 pfet_03v3 ad=2.08p pd=8.52u as=2.08p ps=8.52u w=8u l=0.28u
X261 a_4812_41600.t5 CLKN_H.t38 VDD.t171 VDD.t170 pfet_03v3 ad=2.08p pd=8.52u as=2.08p ps=8.52u w=8u l=0.28u
X262 O_CAPTURE_CLK.t12 a_4812_41600.t12 VSS.t145 VSS.t144 nfet_03v3 ad=2.08p pd=8.52u as=2.08p ps=8.52u w=8u l=0.28u
X263 E_CAPTURE_CLK.t14 a_4812_6400.t22 VDD.t271 VDD.t270 pfet_03v3 ad=2.08p pd=8.52u as=2.08p ps=8.52u w=8u l=0.28u
X264 VSS.t23 a_6924_6400.t37 E_SENSE.t11 VSS.t22 nfet_03v3 ad=2.08p pd=8.52u as=2.08p ps=8.52u w=8u l=0.28u
X265 VSS.t61 a_4812_6400.t11 E_CAPTURE_CLK.t8 VSS.t60 nfet_03v3 ad=2.08p pd=8.52u as=2.08p ps=8.52u w=8u l=0.28u
X266 VDD.t163 CLKN_H.t25 a_6924_41600.t26 VDD.t162 pfet_03v3 ad=2.08p pd=8.52u as=2.08p ps=8.52u w=8u l=0.28u
X267 VSS.t73 a_6924_41600.t55 O_SENSE.t28 VSS.t72 nfet_03v3 ad=2.08p pd=8.52u as=2.08p ps=8.52u w=8u l=0.28u
X268 a_4812_6400.t7 CLKP_H.t36 VDD.t225 VDD.t224 pfet_03v3 ad=3.52p pd=16.88u as=2.08p ps=8.52u w=8u l=0.28u
X269 E_CAPTURE_CLK.t5 a_4812_6400.t20 VDD.t83 VDD.t82 pfet_03v3 ad=2.08p pd=8.52u as=2.08p ps=8.52u w=8u l=0.28u
X270 VSS.t105 a_6924_6400.t35 E_SENSE.t34 VSS.t104 nfet_03v3 ad=2.08p pd=8.52u as=2.08p ps=8.52u w=8u l=0.28u
X271 VSS.t3 a_6924_6400.t43 E_SENSE.t4 VSS.t2 nfet_03v3 ad=2.08p pd=8.52u as=2.08p ps=8.52u w=8u l=0.28u
X272 E_SENSE.t31 a_6924_6400.t70 VDD.t107 VDD.t106 pfet_03v3 ad=2.08p pd=8.52u as=2.08p ps=8.52u w=8u l=0.28u
X273 O_CAPTURE_CLK.t4 a_4812_41600.t18 VDD.t71 VDD.t70 pfet_03v3 ad=2.08p pd=8.52u as=2.08p ps=8.52u w=8u l=0.28u
X274 VSS.t189 CLKN_H.t17 a_4812_41600.t2 VSS.t188 nfet_03v3 ad=2.08p pd=8.52u as=2.08p ps=8.52u w=8u l=0.28u
X275 E_SENSE.t39 a_6924_6400.t76 VDD.t137 VDD.t136 pfet_03v3 ad=2.08p pd=8.52u as=2.08p ps=8.52u w=8u l=0.28u
X276 VDD.t203 CLKN_HB.t5 a_2700_41600.t6 VDD.t202 pfet_03v3 ad=2.08p pd=8.52u as=2.08p ps=8.52u w=8u l=0.28u
X277 a_6924_41600.t17 CLKN_H.t34 VDD.t169 VDD.t168 pfet_03v3 ad=2.08p pd=8.52u as=2.08p ps=8.52u w=8u l=0.28u
X278 VDD.t161 CLKP_HB.t5 a_2700_6400.t6 VDD.t160 pfet_03v3 ad=2.08p pd=8.52u as=2.08p ps=8.52u w=8u l=0.28u
X279 VSS.t97 a_4812_41600.t9 O_CAPTURE_CLK.t9 VSS.t96 nfet_03v3 ad=2.08p pd=8.52u as=2.08p ps=8.52u w=8u l=0.28u
X280 VSS.t181 CLKN_H.t13 a_6924_41600.t2 VSS.t180 nfet_03v3 ad=2.08p pd=8.52u as=2.08p ps=8.52u w=8u l=0.28u
X281 VDD.t217 CLKP_H.t39 a_4812_6400.t4 VDD.t216 pfet_03v3 ad=2.08p pd=8.52u as=3.52p ps=16.88u w=8u l=0.28u
X282 VDD.t223 CLKP_H.t37 a_4812_6400.t6 VDD.t222 pfet_03v3 ad=2.08p pd=8.52u as=2.08p ps=8.52u w=8u l=0.28u
X283 VDD.t259 a_4812_6400.t21 E_CAPTURE_CLK.t12 VDD.t258 pfet_03v3 ad=2.08p pd=8.52u as=2.08p ps=8.52u w=8u l=0.28u
X284 VDD.t181 CLKN_H.t31 a_6924_41600.t20 VDD.t180 pfet_03v3 ad=2.08p pd=8.52u as=2.08p ps=8.52u w=8u l=0.28u
X285 VSS.t71 a_6924_41600.t61 O_SENSE.t27 VSS.t70 nfet_03v3 ad=2.08p pd=8.52u as=2.08p ps=8.52u w=8u l=0.28u
X286 a_6924_6400.t3 CLKP_H.t12 VSS.t239 VSS.t238 nfet_03v3 ad=2.08p pd=8.52u as=2.08p ps=8.52u w=8u l=0.28u
X287 VDD.t5 a_6924_6400.t77 E_SENSE.t2 VDD.t4 pfet_03v3 ad=2.08p pd=8.52u as=2.08p ps=8.52u w=8u l=0.28u
R0 E_SENSE E_SENSE.n62 10.372
R1 E_SENSE.n62 E_SENSE.n30 6.21777
R2 E_SENSE.n32 E_SENSE.t24 5.7796
R3 E_SENSE.n1 E_SENSE.t26 5.73764
R4 E_SENSE.n61 E_SENSE.t32 5.59012
R5 E_SENSE.n30 E_SENSE.t56 5.54817
R6 E_SENSE.n32 E_SENSE.n31 5.38537
R7 E_SENSE.n34 E_SENSE.n33 5.38537
R8 E_SENSE.n36 E_SENSE.n35 5.38537
R9 E_SENSE.n38 E_SENSE.n37 5.38537
R10 E_SENSE.n40 E_SENSE.n39 5.38537
R11 E_SENSE.n42 E_SENSE.n41 5.38537
R12 E_SENSE.n44 E_SENSE.n43 5.38537
R13 E_SENSE.n46 E_SENSE.n45 5.38537
R14 E_SENSE.n48 E_SENSE.n47 5.38537
R15 E_SENSE.n50 E_SENSE.n49 5.38537
R16 E_SENSE.n52 E_SENSE.n51 5.38537
R17 E_SENSE.n54 E_SENSE.n53 5.38537
R18 E_SENSE.n56 E_SENSE.n55 5.38537
R19 E_SENSE.n58 E_SENSE.n57 5.38537
R20 E_SENSE.n60 E_SENSE.n59 5.38537
R21 E_SENSE.n1 E_SENSE.n0 5.32067
R22 E_SENSE.n3 E_SENSE.n2 5.32067
R23 E_SENSE.n5 E_SENSE.n4 5.32067
R24 E_SENSE.n7 E_SENSE.n6 5.32067
R25 E_SENSE.n9 E_SENSE.n8 5.32067
R26 E_SENSE.n11 E_SENSE.n10 5.32067
R27 E_SENSE.n13 E_SENSE.n12 5.32067
R28 E_SENSE.n15 E_SENSE.n14 5.32067
R29 E_SENSE.n17 E_SENSE.n16 5.32067
R30 E_SENSE.n19 E_SENSE.n18 5.32067
R31 E_SENSE.n21 E_SENSE.n20 5.32067
R32 E_SENSE.n23 E_SENSE.n22 5.32067
R33 E_SENSE.n25 E_SENSE.n24 5.32067
R34 E_SENSE.n27 E_SENSE.n26 5.32067
R35 E_SENSE.n29 E_SENSE.n28 5.32067
R36 E_SENSE.n62 E_SENSE.n61 4.93206
R37 E_SENSE.n0 E_SENSE.t40 0.228
R38 E_SENSE.n0 E_SENSE.t61 0.228
R39 E_SENSE.n2 E_SENSE.t53 0.228
R40 E_SENSE.n2 E_SENSE.t38 0.228
R41 E_SENSE.n4 E_SENSE.t31 0.228
R42 E_SENSE.n4 E_SENSE.t41 0.228
R43 E_SENSE.n6 E_SENSE.t10 0.228
R44 E_SENSE.n6 E_SENSE.t25 0.228
R45 E_SENSE.n8 E_SENSE.t60 0.228
R46 E_SENSE.n8 E_SENSE.t15 0.228
R47 E_SENSE.n10 E_SENSE.t39 0.228
R48 E_SENSE.n10 E_SENSE.t20 0.228
R49 E_SENSE.n12 E_SENSE.t37 0.228
R50 E_SENSE.n12 E_SENSE.t2 0.228
R51 E_SENSE.n14 E_SENSE.t36 0.228
R52 E_SENSE.n14 E_SENSE.t52 0.228
R53 E_SENSE.n16 E_SENSE.t14 0.228
R54 E_SENSE.n16 E_SENSE.t9 0.228
R55 E_SENSE.n18 E_SENSE.t1 0.228
R56 E_SENSE.n18 E_SENSE.t19 0.228
R57 E_SENSE.n20 E_SENSE.t8 0.228
R58 E_SENSE.n20 E_SENSE.t33 0.228
R59 E_SENSE.n22 E_SENSE.t18 0.228
R60 E_SENSE.n22 E_SENSE.t13 0.228
R61 E_SENSE.n24 E_SENSE.t43 0.228
R62 E_SENSE.n24 E_SENSE.t0 0.228
R63 E_SENSE.n26 E_SENSE.t58 0.228
R64 E_SENSE.n26 E_SENSE.t59 0.228
R65 E_SENSE.n28 E_SENSE.t50 0.228
R66 E_SENSE.n28 E_SENSE.t57 0.228
R67 E_SENSE.n31 E_SENSE.t7 0.20525
R68 E_SENSE.n31 E_SENSE.t6 0.20525
R69 E_SENSE.n33 E_SENSE.t35 0.20525
R70 E_SENSE.n33 E_SENSE.t34 0.20525
R71 E_SENSE.n35 E_SENSE.t12 0.20525
R72 E_SENSE.n35 E_SENSE.t11 0.20525
R73 E_SENSE.n37 E_SENSE.t17 0.20525
R74 E_SENSE.n37 E_SENSE.t16 0.20525
R75 E_SENSE.n39 E_SENSE.t23 0.20525
R76 E_SENSE.n39 E_SENSE.t22 0.20525
R77 E_SENSE.n41 E_SENSE.t5 0.20525
R78 E_SENSE.n41 E_SENSE.t4 0.20525
R79 E_SENSE.n43 E_SENSE.t47 0.20525
R80 E_SENSE.n43 E_SENSE.t46 0.20525
R81 E_SENSE.n45 E_SENSE.t45 0.20525
R82 E_SENSE.n45 E_SENSE.t44 0.20525
R83 E_SENSE.n47 E_SENSE.t49 0.20525
R84 E_SENSE.n47 E_SENSE.t48 0.20525
R85 E_SENSE.n49 E_SENSE.t30 0.20525
R86 E_SENSE.n49 E_SENSE.t29 0.20525
R87 E_SENSE.n51 E_SENSE.t55 0.20525
R88 E_SENSE.n51 E_SENSE.t54 0.20525
R89 E_SENSE.n53 E_SENSE.t28 0.20525
R90 E_SENSE.n53 E_SENSE.t27 0.20525
R91 E_SENSE.n55 E_SENSE.t63 0.20525
R92 E_SENSE.n55 E_SENSE.t62 0.20525
R93 E_SENSE.n57 E_SENSE.t3 0.20525
R94 E_SENSE.n57 E_SENSE.t21 0.20525
R95 E_SENSE.n59 E_SENSE.t42 0.20525
R96 E_SENSE.n59 E_SENSE.t51 0.20525
R97 E_SENSE.n61 E_SENSE.n60 0.189974
R98 E_SENSE.n60 E_SENSE.n58 0.189974
R99 E_SENSE.n58 E_SENSE.n56 0.189974
R100 E_SENSE.n56 E_SENSE.n54 0.189974
R101 E_SENSE.n54 E_SENSE.n52 0.189974
R102 E_SENSE.n52 E_SENSE.n50 0.189974
R103 E_SENSE.n50 E_SENSE.n48 0.189974
R104 E_SENSE.n48 E_SENSE.n46 0.189974
R105 E_SENSE.n46 E_SENSE.n44 0.189974
R106 E_SENSE.n44 E_SENSE.n42 0.189974
R107 E_SENSE.n42 E_SENSE.n40 0.189974
R108 E_SENSE.n40 E_SENSE.n38 0.189974
R109 E_SENSE.n38 E_SENSE.n36 0.189974
R110 E_SENSE.n36 E_SENSE.n34 0.189974
R111 E_SENSE.n34 E_SENSE.n32 0.189974
R112 E_SENSE.n30 E_SENSE.n29 0.189974
R113 E_SENSE.n29 E_SENSE.n27 0.189974
R114 E_SENSE.n27 E_SENSE.n25 0.189974
R115 E_SENSE.n25 E_SENSE.n23 0.189974
R116 E_SENSE.n23 E_SENSE.n21 0.189974
R117 E_SENSE.n21 E_SENSE.n19 0.189974
R118 E_SENSE.n19 E_SENSE.n17 0.189974
R119 E_SENSE.n17 E_SENSE.n15 0.189974
R120 E_SENSE.n15 E_SENSE.n13 0.189974
R121 E_SENSE.n13 E_SENSE.n11 0.189974
R122 E_SENSE.n11 E_SENSE.n9 0.189974
R123 E_SENSE.n9 E_SENSE.n7 0.189974
R124 E_SENSE.n7 E_SENSE.n5 0.189974
R125 E_SENSE.n5 E_SENSE.n3 0.189974
R126 E_SENSE.n3 E_SENSE.n1 0.189974
R127 E_CAPTURE_CLK E_CAPTURE_CLK.n14 6.63157
R128 E_CAPTURE_CLK.n14 E_CAPTURE_CLK.n6 6.5392
R129 E_CAPTURE_CLK.n8 E_CAPTURE_CLK.t10 5.7796
R130 E_CAPTURE_CLK.n1 E_CAPTURE_CLK.t6 5.73764
R131 E_CAPTURE_CLK.n13 E_CAPTURE_CLK.t2 5.59012
R132 E_CAPTURE_CLK.n6 E_CAPTURE_CLK.t9 5.54817
R133 E_CAPTURE_CLK.n8 E_CAPTURE_CLK.n7 5.38537
R134 E_CAPTURE_CLK.n10 E_CAPTURE_CLK.n9 5.38537
R135 E_CAPTURE_CLK.n12 E_CAPTURE_CLK.n11 5.38537
R136 E_CAPTURE_CLK.n1 E_CAPTURE_CLK.n0 5.32067
R137 E_CAPTURE_CLK.n3 E_CAPTURE_CLK.n2 5.32067
R138 E_CAPTURE_CLK.n5 E_CAPTURE_CLK.n4 5.32067
R139 E_CAPTURE_CLK.n14 E_CAPTURE_CLK.n13 4.61063
R140 E_CAPTURE_CLK.n0 E_CAPTURE_CLK.t3 0.228
R141 E_CAPTURE_CLK.n0 E_CAPTURE_CLK.t4 0.228
R142 E_CAPTURE_CLK.n2 E_CAPTURE_CLK.t5 0.228
R143 E_CAPTURE_CLK.n2 E_CAPTURE_CLK.t1 0.228
R144 E_CAPTURE_CLK.n4 E_CAPTURE_CLK.t14 0.228
R145 E_CAPTURE_CLK.n4 E_CAPTURE_CLK.t12 0.228
R146 E_CAPTURE_CLK.n7 E_CAPTURE_CLK.t11 0.20525
R147 E_CAPTURE_CLK.n7 E_CAPTURE_CLK.t13 0.20525
R148 E_CAPTURE_CLK.n9 E_CAPTURE_CLK.t7 0.20525
R149 E_CAPTURE_CLK.n9 E_CAPTURE_CLK.t8 0.20525
R150 E_CAPTURE_CLK.n11 E_CAPTURE_CLK.t15 0.20525
R151 E_CAPTURE_CLK.n11 E_CAPTURE_CLK.t0 0.20525
R152 E_CAPTURE_CLK.n13 E_CAPTURE_CLK.n12 0.189974
R153 E_CAPTURE_CLK.n12 E_CAPTURE_CLK.n10 0.189974
R154 E_CAPTURE_CLK.n10 E_CAPTURE_CLK.n8 0.189974
R155 E_CAPTURE_CLK.n6 E_CAPTURE_CLK.n5 0.189974
R156 E_CAPTURE_CLK.n5 E_CAPTURE_CLK.n3 0.189974
R157 E_CAPTURE_CLK.n3 E_CAPTURE_CLK.n1 0.189974
R158 E_CAPTURE_CLKB E_CAPTURE_CLKB.n14 6.96907
R159 E_CAPTURE_CLKB.n14 E_CAPTURE_CLKB.n6 6.5392
R160 E_CAPTURE_CLKB.n8 E_CAPTURE_CLKB.t0 5.7796
R161 E_CAPTURE_CLKB.n1 E_CAPTURE_CLKB.t6 5.73764
R162 E_CAPTURE_CLKB.n13 E_CAPTURE_CLKB.t1 5.59012
R163 E_CAPTURE_CLKB.n6 E_CAPTURE_CLKB.t13 5.54817
R164 E_CAPTURE_CLKB.n8 E_CAPTURE_CLKB.n7 5.38537
R165 E_CAPTURE_CLKB.n10 E_CAPTURE_CLKB.n9 5.38537
R166 E_CAPTURE_CLKB.n12 E_CAPTURE_CLKB.n11 5.38537
R167 E_CAPTURE_CLKB.n1 E_CAPTURE_CLKB.n0 5.32067
R168 E_CAPTURE_CLKB.n3 E_CAPTURE_CLKB.n2 5.32067
R169 E_CAPTURE_CLKB.n5 E_CAPTURE_CLKB.n4 5.32067
R170 E_CAPTURE_CLKB.n14 E_CAPTURE_CLKB.n13 4.61063
R171 E_CAPTURE_CLKB.n0 E_CAPTURE_CLKB.t5 0.228
R172 E_CAPTURE_CLKB.n0 E_CAPTURE_CLKB.t7 0.228
R173 E_CAPTURE_CLKB.n2 E_CAPTURE_CLKB.t2 0.228
R174 E_CAPTURE_CLKB.n2 E_CAPTURE_CLKB.t8 0.228
R175 E_CAPTURE_CLKB.n4 E_CAPTURE_CLKB.t12 0.228
R176 E_CAPTURE_CLKB.n4 E_CAPTURE_CLKB.t4 0.228
R177 E_CAPTURE_CLKB.n7 E_CAPTURE_CLKB.t11 0.20525
R178 E_CAPTURE_CLKB.n7 E_CAPTURE_CLKB.t10 0.20525
R179 E_CAPTURE_CLKB.n9 E_CAPTURE_CLKB.t9 0.20525
R180 E_CAPTURE_CLKB.n9 E_CAPTURE_CLKB.t3 0.20525
R181 E_CAPTURE_CLKB.n11 E_CAPTURE_CLKB.t14 0.20525
R182 E_CAPTURE_CLKB.n11 E_CAPTURE_CLKB.t15 0.20525
R183 E_CAPTURE_CLKB.n13 E_CAPTURE_CLKB.n12 0.189974
R184 E_CAPTURE_CLKB.n12 E_CAPTURE_CLKB.n10 0.189974
R185 E_CAPTURE_CLKB.n10 E_CAPTURE_CLKB.n8 0.189974
R186 E_CAPTURE_CLKB.n6 E_CAPTURE_CLKB.n5 0.189974
R187 E_CAPTURE_CLKB.n5 E_CAPTURE_CLKB.n3 0.189974
R188 E_CAPTURE_CLKB.n3 E_CAPTURE_CLKB.n1 0.189974
R189 CLKP_H.n35 CLKP_H.t15 113.632
R190 CLKP_H.n45 CLKP_H.t0 113.632
R191 CLKP_H.n6 CLKP_H.t35 113.632
R192 CLKP_H.n16 CLKP_H.t20 113.632
R193 CLKP_H.n67 CLKP_H.t19 113.632
R194 CLKP_H.n64 CLKP_H.t16 113.632
R195 CLKP_H.n59 CLKP_H.t36 113.632
R196 CLKP_H.n62 CLKP_H.t39 113.632
R197 CLKP_H.n54 CLKP_H.t7 109.174
R198 CLKP_H.n55 CLKP_H.t8 109.174
R199 CLKP_H.n36 CLKP_H.t14 109.174
R200 CLKP_H.n37 CLKP_H.t13 109.174
R201 CLKP_H.n38 CLKP_H.t12 109.174
R202 CLKP_H.n39 CLKP_H.t11 109.174
R203 CLKP_H.n40 CLKP_H.t10 109.174
R204 CLKP_H.n41 CLKP_H.t9 109.174
R205 CLKP_H.n53 CLKP_H.t6 109.174
R206 CLKP_H.n42 CLKP_H.t5 109.174
R207 CLKP_H.n49 CLKP_H.t4 109.174
R208 CLKP_H.n48 CLKP_H.t3 109.174
R209 CLKP_H.n47 CLKP_H.t2 109.174
R210 CLKP_H.n44 CLKP_H.t1 109.174
R211 CLKP_H.n25 CLKP_H.t27 109.174
R212 CLKP_H.n26 CLKP_H.t28 109.174
R213 CLKP_H.n7 CLKP_H.t34 109.174
R214 CLKP_H.n8 CLKP_H.t33 109.174
R215 CLKP_H.n9 CLKP_H.t32 109.174
R216 CLKP_H.n10 CLKP_H.t31 109.174
R217 CLKP_H.n11 CLKP_H.t30 109.174
R218 CLKP_H.n12 CLKP_H.t29 109.174
R219 CLKP_H.n24 CLKP_H.t26 109.174
R220 CLKP_H.n13 CLKP_H.t25 109.174
R221 CLKP_H.n20 CLKP_H.t24 109.174
R222 CLKP_H.n19 CLKP_H.t23 109.174
R223 CLKP_H.n18 CLKP_H.t22 109.174
R224 CLKP_H.n15 CLKP_H.t21 109.174
R225 CLKP_H.n65 CLKP_H.t17 109.174
R226 CLKP_H.n66 CLKP_H.t18 109.174
R227 CLKP_H.n60 CLKP_H.t37 109.174
R228 CLKP_H.n61 CLKP_H.t38 109.174
R229 CLKP_H.n54 CLKP_H.n29 18.4942
R230 CLKP_H.n56 CLKP_H.n55 18.4942
R231 CLKP_H.n37 CLKP_H.n34 18.4942
R232 CLKP_H.n38 CLKP_H.n33 18.4942
R233 CLKP_H.n39 CLKP_H.n32 18.4942
R234 CLKP_H.n40 CLKP_H.n31 18.4942
R235 CLKP_H.n41 CLKP_H.n30 18.4942
R236 CLKP_H.n53 CLKP_H.n52 18.4942
R237 CLKP_H.n51 CLKP_H.n42 18.4942
R238 CLKP_H.n50 CLKP_H.n49 18.4942
R239 CLKP_H.n48 CLKP_H.n43 18.4942
R240 CLKP_H.n47 CLKP_H.n46 18.4942
R241 CLKP_H.n25 CLKP_H.n0 18.4942
R242 CLKP_H.n27 CLKP_H.n26 18.4942
R243 CLKP_H.n8 CLKP_H.n5 18.4942
R244 CLKP_H.n9 CLKP_H.n4 18.4942
R245 CLKP_H.n10 CLKP_H.n3 18.4942
R246 CLKP_H.n11 CLKP_H.n2 18.4942
R247 CLKP_H.n12 CLKP_H.n1 18.4942
R248 CLKP_H.n24 CLKP_H.n23 18.4942
R249 CLKP_H.n22 CLKP_H.n13 18.4942
R250 CLKP_H.n21 CLKP_H.n20 18.4942
R251 CLKP_H.n19 CLKP_H.n14 18.4942
R252 CLKP_H.n18 CLKP_H.n17 18.4942
R253 CLKP_H.n70 CLKP_H.n58 15.4821
R254 CLKP_H.n70 CLKP_H.n69 14.6737
R255 CLKP_H.n54 CLKP_H.n53 11.6805
R256 CLKP_H.n55 CLKP_H.n54 11.6805
R257 CLKP_H.n37 CLKP_H.n36 11.6805
R258 CLKP_H.n38 CLKP_H.n37 11.6805
R259 CLKP_H.n39 CLKP_H.n38 11.6805
R260 CLKP_H.n40 CLKP_H.n39 11.6805
R261 CLKP_H.n41 CLKP_H.n40 11.6805
R262 CLKP_H.n55 CLKP_H.n41 11.6805
R263 CLKP_H.n53 CLKP_H.n42 11.6805
R264 CLKP_H.n49 CLKP_H.n42 11.6805
R265 CLKP_H.n49 CLKP_H.n48 11.6805
R266 CLKP_H.n48 CLKP_H.n47 11.6805
R267 CLKP_H.n47 CLKP_H.n44 11.6805
R268 CLKP_H.n25 CLKP_H.n24 11.6805
R269 CLKP_H.n26 CLKP_H.n25 11.6805
R270 CLKP_H.n8 CLKP_H.n7 11.6805
R271 CLKP_H.n9 CLKP_H.n8 11.6805
R272 CLKP_H.n10 CLKP_H.n9 11.6805
R273 CLKP_H.n11 CLKP_H.n10 11.6805
R274 CLKP_H.n12 CLKP_H.n11 11.6805
R275 CLKP_H.n26 CLKP_H.n12 11.6805
R276 CLKP_H.n24 CLKP_H.n13 11.6805
R277 CLKP_H.n20 CLKP_H.n13 11.6805
R278 CLKP_H.n20 CLKP_H.n19 11.6805
R279 CLKP_H.n19 CLKP_H.n18 11.6805
R280 CLKP_H.n18 CLKP_H.n15 11.6805
R281 CLKP_H.n66 CLKP_H.n65 11.6805
R282 CLKP_H.n61 CLKP_H.n60 11.6805
R283 CLKP_H.n58 CLKP_H.n28 10.9291
R284 CLKP_H.n69 CLKP_H.n63 10.9291
R285 CLKP_H.n58 CLKP_H.n57 9.0005
R286 CLKP_H.n69 CLKP_H.n68 9.0005
R287 CLKP_H.n46 CLKP_H.n45 7.17687
R288 CLKP_H.n35 CLKP_H.n34 7.17687
R289 CLKP_H.n17 CLKP_H.n16 7.17687
R290 CLKP_H.n6 CLKP_H.n5 7.17687
R291 CLKP_H.n68 CLKP_H.n64 7.10487
R292 CLKP_H.n68 CLKP_H.n67 7.10487
R293 CLKP_H.n63 CLKP_H.n59 7.10487
R294 CLKP_H.n63 CLKP_H.n62 7.10487
R295 CLKP_H.n36 CLKP_H.n35 4.42851
R296 CLKP_H.n45 CLKP_H.n44 4.42851
R297 CLKP_H.n7 CLKP_H.n6 4.42851
R298 CLKP_H.n16 CLKP_H.n15 4.42851
R299 CLKP_H.n65 CLKP_H.n64 4.42851
R300 CLKP_H.n67 CLKP_H.n66 4.42851
R301 CLKP_H.n60 CLKP_H.n59 4.42851
R302 CLKP_H.n62 CLKP_H.n61 4.42851
R303 CLKP_H CLKP_H.n70 0.714184
R304 CLKP_H.n52 CLKP_H.n29 0.1205
R305 CLKP_H.n52 CLKP_H.n51 0.1205
R306 CLKP_H.n51 CLKP_H.n50 0.1205
R307 CLKP_H.n50 CLKP_H.n43 0.1205
R308 CLKP_H.n46 CLKP_H.n43 0.1205
R309 CLKP_H.n34 CLKP_H.n33 0.1205
R310 CLKP_H.n33 CLKP_H.n32 0.1205
R311 CLKP_H.n32 CLKP_H.n31 0.1205
R312 CLKP_H.n31 CLKP_H.n30 0.1205
R313 CLKP_H.n56 CLKP_H.n30 0.1205
R314 CLKP_H.n23 CLKP_H.n0 0.1205
R315 CLKP_H.n23 CLKP_H.n22 0.1205
R316 CLKP_H.n22 CLKP_H.n21 0.1205
R317 CLKP_H.n21 CLKP_H.n14 0.1205
R318 CLKP_H.n17 CLKP_H.n14 0.1205
R319 CLKP_H.n5 CLKP_H.n4 0.1205
R320 CLKP_H.n4 CLKP_H.n3 0.1205
R321 CLKP_H.n3 CLKP_H.n2 0.1205
R322 CLKP_H.n2 CLKP_H.n1 0.1205
R323 CLKP_H.n27 CLKP_H.n1 0.1205
R324 CLKP_H.n57 CLKP_H.n29 0.0485
R325 CLKP_H.n57 CLKP_H.n56 0.0485
R326 CLKP_H.n28 CLKP_H.n0 0.0485
R327 CLKP_H.n28 CLKP_H.n27 0.0485
R328 CLKP_HB.n8 CLKP_HB.t3 113.632
R329 CLKP_HB.n5 CLKP_HB.t0 113.632
R330 CLKP_HB.n0 CLKP_HB.t4 113.632
R331 CLKP_HB.n3 CLKP_HB.t7 113.632
R332 CLKP_HB.n6 CLKP_HB.t1 109.174
R333 CLKP_HB.n7 CLKP_HB.t2 109.174
R334 CLKP_HB.n1 CLKP_HB.t5 109.174
R335 CLKP_HB.n2 CLKP_HB.t6 109.174
R336 CLKP_HB CLKP_HB.n10 12.85
R337 CLKP_HB.n7 CLKP_HB.n6 11.6805
R338 CLKP_HB.n2 CLKP_HB.n1 11.6805
R339 CLKP_HB.n10 CLKP_HB.n4 10.9291
R340 CLKP_HB.n10 CLKP_HB.n9 9.0005
R341 CLKP_HB.n9 CLKP_HB.n5 7.10487
R342 CLKP_HB.n9 CLKP_HB.n8 7.10487
R343 CLKP_HB.n4 CLKP_HB.n0 7.10487
R344 CLKP_HB.n4 CLKP_HB.n3 7.10487
R345 CLKP_HB.n6 CLKP_HB.n5 4.42851
R346 CLKP_HB.n8 CLKP_HB.n7 4.42851
R347 CLKP_HB.n1 CLKP_HB.n0 4.42851
R348 CLKP_HB.n3 CLKP_HB.n2 4.42851
R349 O_SENSE O_SENSE.n62 10.372
R350 O_SENSE.n62 O_SENSE.n30 6.21777
R351 O_SENSE.n32 O_SENSE.t31 5.7796
R352 O_SENSE.n1 O_SENSE.t10 5.73764
R353 O_SENSE.n61 O_SENSE.t23 5.59012
R354 O_SENSE.n30 O_SENSE.t0 5.54817
R355 O_SENSE.n32 O_SENSE.n31 5.38537
R356 O_SENSE.n34 O_SENSE.n33 5.38537
R357 O_SENSE.n36 O_SENSE.n35 5.38537
R358 O_SENSE.n38 O_SENSE.n37 5.38537
R359 O_SENSE.n40 O_SENSE.n39 5.38537
R360 O_SENSE.n42 O_SENSE.n41 5.38537
R361 O_SENSE.n44 O_SENSE.n43 5.38537
R362 O_SENSE.n46 O_SENSE.n45 5.38537
R363 O_SENSE.n48 O_SENSE.n47 5.38537
R364 O_SENSE.n50 O_SENSE.n49 5.38537
R365 O_SENSE.n52 O_SENSE.n51 5.38537
R366 O_SENSE.n54 O_SENSE.n53 5.38537
R367 O_SENSE.n56 O_SENSE.n55 5.38537
R368 O_SENSE.n58 O_SENSE.n57 5.38537
R369 O_SENSE.n60 O_SENSE.n59 5.38537
R370 O_SENSE.n1 O_SENSE.n0 5.32067
R371 O_SENSE.n3 O_SENSE.n2 5.32067
R372 O_SENSE.n5 O_SENSE.n4 5.32067
R373 O_SENSE.n7 O_SENSE.n6 5.32067
R374 O_SENSE.n9 O_SENSE.n8 5.32067
R375 O_SENSE.n11 O_SENSE.n10 5.32067
R376 O_SENSE.n13 O_SENSE.n12 5.32067
R377 O_SENSE.n15 O_SENSE.n14 5.32067
R378 O_SENSE.n17 O_SENSE.n16 5.32067
R379 O_SENSE.n19 O_SENSE.n18 5.32067
R380 O_SENSE.n21 O_SENSE.n20 5.32067
R381 O_SENSE.n23 O_SENSE.n22 5.32067
R382 O_SENSE.n25 O_SENSE.n24 5.32067
R383 O_SENSE.n27 O_SENSE.n26 5.32067
R384 O_SENSE.n29 O_SENSE.n28 5.32067
R385 O_SENSE.n62 O_SENSE.n61 4.93206
R386 O_SENSE.n0 O_SENSE.t16 0.228
R387 O_SENSE.n0 O_SENSE.t3 0.228
R388 O_SENSE.n2 O_SENSE.t9 0.228
R389 O_SENSE.n2 O_SENSE.t22 0.228
R390 O_SENSE.n4 O_SENSE.t63 0.228
R391 O_SENSE.n4 O_SENSE.t52 0.228
R392 O_SENSE.n6 O_SENSE.t8 0.228
R393 O_SENSE.n6 O_SENSE.t21 0.228
R394 O_SENSE.n8 O_SENSE.t41 0.228
R395 O_SENSE.n8 O_SENSE.t58 0.228
R396 O_SENSE.n10 O_SENSE.t20 0.228
R397 O_SENSE.n10 O_SENSE.t32 0.228
R398 O_SENSE.n12 O_SENSE.t39 0.228
R399 O_SENSE.n12 O_SENSE.t7 0.228
R400 O_SENSE.n14 O_SENSE.t15 0.228
R401 O_SENSE.n14 O_SENSE.t2 0.228
R402 O_SENSE.n16 O_SENSE.t62 0.228
R403 O_SENSE.n16 O_SENSE.t37 0.228
R404 O_SENSE.n18 O_SENSE.t29 0.228
R405 O_SENSE.n18 O_SENSE.t40 0.228
R406 O_SENSE.n20 O_SENSE.t36 0.228
R407 O_SENSE.n20 O_SENSE.t38 0.228
R408 O_SENSE.n22 O_SENSE.t34 0.228
R409 O_SENSE.n22 O_SENSE.t61 0.228
R410 O_SENSE.n24 O_SENSE.t6 0.228
R411 O_SENSE.n24 O_SENSE.t19 0.228
R412 O_SENSE.n26 O_SENSE.t14 0.228
R413 O_SENSE.n26 O_SENSE.t1 0.228
R414 O_SENSE.n28 O_SENSE.t5 0.228
R415 O_SENSE.n28 O_SENSE.t18 0.228
R416 O_SENSE.n31 O_SENSE.t26 0.20525
R417 O_SENSE.n31 O_SENSE.t25 0.20525
R418 O_SENSE.n33 O_SENSE.t13 0.20525
R419 O_SENSE.n33 O_SENSE.t12 0.20525
R420 O_SENSE.n35 O_SENSE.t60 0.20525
R421 O_SENSE.n35 O_SENSE.t59 0.20525
R422 O_SENSE.n37 O_SENSE.t57 0.20525
R423 O_SENSE.n37 O_SENSE.t56 0.20525
R424 O_SENSE.n39 O_SENSE.t50 0.20525
R425 O_SENSE.n39 O_SENSE.t49 0.20525
R426 O_SENSE.n41 O_SENSE.t45 0.20525
R427 O_SENSE.n41 O_SENSE.t44 0.20525
R428 O_SENSE.n43 O_SENSE.t55 0.20525
R429 O_SENSE.n43 O_SENSE.t54 0.20525
R430 O_SENSE.n45 O_SENSE.t48 0.20525
R431 O_SENSE.n45 O_SENSE.t47 0.20525
R432 O_SENSE.n47 O_SENSE.t51 0.20525
R433 O_SENSE.n47 O_SENSE.t43 0.20525
R434 O_SENSE.n49 O_SENSE.t46 0.20525
R435 O_SENSE.n49 O_SENSE.t53 0.20525
R436 O_SENSE.n51 O_SENSE.t33 0.20525
R437 O_SENSE.n51 O_SENSE.t42 0.20525
R438 O_SENSE.n53 O_SENSE.t30 0.20525
R439 O_SENSE.n53 O_SENSE.t28 0.20525
R440 O_SENSE.n55 O_SENSE.t11 0.20525
R441 O_SENSE.n55 O_SENSE.t24 0.20525
R442 O_SENSE.n57 O_SENSE.t17 0.20525
R443 O_SENSE.n57 O_SENSE.t4 0.20525
R444 O_SENSE.n59 O_SENSE.t35 0.20525
R445 O_SENSE.n59 O_SENSE.t27 0.20525
R446 O_SENSE.n61 O_SENSE.n60 0.189974
R447 O_SENSE.n60 O_SENSE.n58 0.189974
R448 O_SENSE.n58 O_SENSE.n56 0.189974
R449 O_SENSE.n56 O_SENSE.n54 0.189974
R450 O_SENSE.n54 O_SENSE.n52 0.189974
R451 O_SENSE.n52 O_SENSE.n50 0.189974
R452 O_SENSE.n50 O_SENSE.n48 0.189974
R453 O_SENSE.n48 O_SENSE.n46 0.189974
R454 O_SENSE.n46 O_SENSE.n44 0.189974
R455 O_SENSE.n44 O_SENSE.n42 0.189974
R456 O_SENSE.n42 O_SENSE.n40 0.189974
R457 O_SENSE.n40 O_SENSE.n38 0.189974
R458 O_SENSE.n38 O_SENSE.n36 0.189974
R459 O_SENSE.n36 O_SENSE.n34 0.189974
R460 O_SENSE.n34 O_SENSE.n32 0.189974
R461 O_SENSE.n30 O_SENSE.n29 0.189974
R462 O_SENSE.n29 O_SENSE.n27 0.189974
R463 O_SENSE.n27 O_SENSE.n25 0.189974
R464 O_SENSE.n25 O_SENSE.n23 0.189974
R465 O_SENSE.n23 O_SENSE.n21 0.189974
R466 O_SENSE.n21 O_SENSE.n19 0.189974
R467 O_SENSE.n19 O_SENSE.n17 0.189974
R468 O_SENSE.n17 O_SENSE.n15 0.189974
R469 O_SENSE.n15 O_SENSE.n13 0.189974
R470 O_SENSE.n13 O_SENSE.n11 0.189974
R471 O_SENSE.n11 O_SENSE.n9 0.189974
R472 O_SENSE.n9 O_SENSE.n7 0.189974
R473 O_SENSE.n7 O_SENSE.n5 0.189974
R474 O_SENSE.n5 O_SENSE.n3 0.189974
R475 O_SENSE.n3 O_SENSE.n1 0.189974
R476 O_CAPTURE_CLK O_CAPTURE_CLK.n14 6.63157
R477 O_CAPTURE_CLK.n14 O_CAPTURE_CLK.n6 6.5392
R478 O_CAPTURE_CLK.n8 O_CAPTURE_CLK.t15 5.7796
R479 O_CAPTURE_CLK.n1 O_CAPTURE_CLK.t2 5.73764
R480 O_CAPTURE_CLK.n13 O_CAPTURE_CLK.t1 5.59012
R481 O_CAPTURE_CLK.n6 O_CAPTURE_CLK.t0 5.54817
R482 O_CAPTURE_CLK.n8 O_CAPTURE_CLK.n7 5.38537
R483 O_CAPTURE_CLK.n10 O_CAPTURE_CLK.n9 5.38537
R484 O_CAPTURE_CLK.n12 O_CAPTURE_CLK.n11 5.38537
R485 O_CAPTURE_CLK.n1 O_CAPTURE_CLK.n0 5.32067
R486 O_CAPTURE_CLK.n3 O_CAPTURE_CLK.n2 5.32067
R487 O_CAPTURE_CLK.n5 O_CAPTURE_CLK.n4 5.32067
R488 O_CAPTURE_CLK.n14 O_CAPTURE_CLK.n13 4.61063
R489 O_CAPTURE_CLK.n0 O_CAPTURE_CLK.t4 0.228
R490 O_CAPTURE_CLK.n0 O_CAPTURE_CLK.t3 0.228
R491 O_CAPTURE_CLK.n2 O_CAPTURE_CLK.t14 0.228
R492 O_CAPTURE_CLK.n2 O_CAPTURE_CLK.t13 0.228
R493 O_CAPTURE_CLK.n4 O_CAPTURE_CLK.t6 0.228
R494 O_CAPTURE_CLK.n4 O_CAPTURE_CLK.t5 0.228
R495 O_CAPTURE_CLK.n7 O_CAPTURE_CLK.t10 0.20525
R496 O_CAPTURE_CLK.n7 O_CAPTURE_CLK.t9 0.20525
R497 O_CAPTURE_CLK.n9 O_CAPTURE_CLK.t12 0.20525
R498 O_CAPTURE_CLK.n9 O_CAPTURE_CLK.t11 0.20525
R499 O_CAPTURE_CLK.n11 O_CAPTURE_CLK.t8 0.20525
R500 O_CAPTURE_CLK.n11 O_CAPTURE_CLK.t7 0.20525
R501 O_CAPTURE_CLK.n13 O_CAPTURE_CLK.n12 0.189974
R502 O_CAPTURE_CLK.n12 O_CAPTURE_CLK.n10 0.189974
R503 O_CAPTURE_CLK.n10 O_CAPTURE_CLK.n8 0.189974
R504 O_CAPTURE_CLK.n6 O_CAPTURE_CLK.n5 0.189974
R505 O_CAPTURE_CLK.n5 O_CAPTURE_CLK.n3 0.189974
R506 O_CAPTURE_CLK.n3 O_CAPTURE_CLK.n1 0.189974
R507 O_CAPTURE_CLKB O_CAPTURE_CLKB.n14 6.96907
R508 O_CAPTURE_CLKB.n14 O_CAPTURE_CLKB.n6 6.5392
R509 O_CAPTURE_CLKB.n8 O_CAPTURE_CLKB.t12 5.7796
R510 O_CAPTURE_CLKB.n1 O_CAPTURE_CLKB.t14 5.73764
R511 O_CAPTURE_CLKB.n13 O_CAPTURE_CLKB.t13 5.59012
R512 O_CAPTURE_CLKB.n6 O_CAPTURE_CLKB.t4 5.54817
R513 O_CAPTURE_CLKB.n8 O_CAPTURE_CLKB.n7 5.38537
R514 O_CAPTURE_CLKB.n10 O_CAPTURE_CLKB.n9 5.38537
R515 O_CAPTURE_CLKB.n12 O_CAPTURE_CLKB.n11 5.38537
R516 O_CAPTURE_CLKB.n1 O_CAPTURE_CLKB.n0 5.32067
R517 O_CAPTURE_CLKB.n3 O_CAPTURE_CLKB.n2 5.32067
R518 O_CAPTURE_CLKB.n5 O_CAPTURE_CLKB.n4 5.32067
R519 O_CAPTURE_CLKB.n14 O_CAPTURE_CLKB.n13 4.61063
R520 O_CAPTURE_CLKB.n0 O_CAPTURE_CLKB.t1 0.228
R521 O_CAPTURE_CLKB.n0 O_CAPTURE_CLKB.t0 0.228
R522 O_CAPTURE_CLKB.n2 O_CAPTURE_CLKB.t7 0.228
R523 O_CAPTURE_CLKB.n2 O_CAPTURE_CLKB.t6 0.228
R524 O_CAPTURE_CLKB.n4 O_CAPTURE_CLKB.t11 0.228
R525 O_CAPTURE_CLKB.n4 O_CAPTURE_CLKB.t10 0.228
R526 O_CAPTURE_CLKB.n7 O_CAPTURE_CLKB.t15 0.20525
R527 O_CAPTURE_CLKB.n7 O_CAPTURE_CLKB.t5 0.20525
R528 O_CAPTURE_CLKB.n9 O_CAPTURE_CLKB.t3 0.20525
R529 O_CAPTURE_CLKB.n9 O_CAPTURE_CLKB.t2 0.20525
R530 O_CAPTURE_CLKB.n11 O_CAPTURE_CLKB.t9 0.20525
R531 O_CAPTURE_CLKB.n11 O_CAPTURE_CLKB.t8 0.20525
R532 O_CAPTURE_CLKB.n13 O_CAPTURE_CLKB.n12 0.189974
R533 O_CAPTURE_CLKB.n12 O_CAPTURE_CLKB.n10 0.189974
R534 O_CAPTURE_CLKB.n10 O_CAPTURE_CLKB.n8 0.189974
R535 O_CAPTURE_CLKB.n6 O_CAPTURE_CLKB.n5 0.189974
R536 O_CAPTURE_CLKB.n5 O_CAPTURE_CLKB.n3 0.189974
R537 O_CAPTURE_CLKB.n3 O_CAPTURE_CLKB.n1 0.189974
R538 CLKN_H.n35 CLKN_H.t15 113.632
R539 CLKN_H.n45 CLKN_H.t0 113.632
R540 CLKN_H.n6 CLKN_H.t35 113.632
R541 CLKN_H.n16 CLKN_H.t20 113.632
R542 CLKN_H.n67 CLKN_H.t19 113.632
R543 CLKN_H.n64 CLKN_H.t16 113.632
R544 CLKN_H.n59 CLKN_H.t36 113.632
R545 CLKN_H.n62 CLKN_H.t39 113.632
R546 CLKN_H.n54 CLKN_H.t7 109.174
R547 CLKN_H.n55 CLKN_H.t8 109.174
R548 CLKN_H.n36 CLKN_H.t14 109.174
R549 CLKN_H.n37 CLKN_H.t13 109.174
R550 CLKN_H.n38 CLKN_H.t12 109.174
R551 CLKN_H.n39 CLKN_H.t11 109.174
R552 CLKN_H.n40 CLKN_H.t10 109.174
R553 CLKN_H.n41 CLKN_H.t9 109.174
R554 CLKN_H.n53 CLKN_H.t6 109.174
R555 CLKN_H.n42 CLKN_H.t5 109.174
R556 CLKN_H.n49 CLKN_H.t4 109.174
R557 CLKN_H.n48 CLKN_H.t3 109.174
R558 CLKN_H.n47 CLKN_H.t2 109.174
R559 CLKN_H.n44 CLKN_H.t1 109.174
R560 CLKN_H.n25 CLKN_H.t27 109.174
R561 CLKN_H.n26 CLKN_H.t28 109.174
R562 CLKN_H.n7 CLKN_H.t34 109.174
R563 CLKN_H.n8 CLKN_H.t33 109.174
R564 CLKN_H.n9 CLKN_H.t32 109.174
R565 CLKN_H.n10 CLKN_H.t31 109.174
R566 CLKN_H.n11 CLKN_H.t30 109.174
R567 CLKN_H.n12 CLKN_H.t29 109.174
R568 CLKN_H.n24 CLKN_H.t26 109.174
R569 CLKN_H.n13 CLKN_H.t25 109.174
R570 CLKN_H.n20 CLKN_H.t24 109.174
R571 CLKN_H.n19 CLKN_H.t23 109.174
R572 CLKN_H.n18 CLKN_H.t22 109.174
R573 CLKN_H.n15 CLKN_H.t21 109.174
R574 CLKN_H.n65 CLKN_H.t17 109.174
R575 CLKN_H.n66 CLKN_H.t18 109.174
R576 CLKN_H.n60 CLKN_H.t37 109.174
R577 CLKN_H.n61 CLKN_H.t38 109.174
R578 CLKN_H.n54 CLKN_H.n29 18.4942
R579 CLKN_H.n56 CLKN_H.n55 18.4942
R580 CLKN_H.n37 CLKN_H.n34 18.4942
R581 CLKN_H.n38 CLKN_H.n33 18.4942
R582 CLKN_H.n39 CLKN_H.n32 18.4942
R583 CLKN_H.n40 CLKN_H.n31 18.4942
R584 CLKN_H.n41 CLKN_H.n30 18.4942
R585 CLKN_H.n53 CLKN_H.n52 18.4942
R586 CLKN_H.n51 CLKN_H.n42 18.4942
R587 CLKN_H.n50 CLKN_H.n49 18.4942
R588 CLKN_H.n48 CLKN_H.n43 18.4942
R589 CLKN_H.n47 CLKN_H.n46 18.4942
R590 CLKN_H.n25 CLKN_H.n0 18.4942
R591 CLKN_H.n27 CLKN_H.n26 18.4942
R592 CLKN_H.n8 CLKN_H.n5 18.4942
R593 CLKN_H.n9 CLKN_H.n4 18.4942
R594 CLKN_H.n10 CLKN_H.n3 18.4942
R595 CLKN_H.n11 CLKN_H.n2 18.4942
R596 CLKN_H.n12 CLKN_H.n1 18.4942
R597 CLKN_H.n24 CLKN_H.n23 18.4942
R598 CLKN_H.n22 CLKN_H.n13 18.4942
R599 CLKN_H.n21 CLKN_H.n20 18.4942
R600 CLKN_H.n19 CLKN_H.n14 18.4942
R601 CLKN_H.n18 CLKN_H.n17 18.4942
R602 CLKN_H.n70 CLKN_H.n58 15.4821
R603 CLKN_H.n70 CLKN_H.n69 14.6737
R604 CLKN_H.n54 CLKN_H.n53 11.6805
R605 CLKN_H.n55 CLKN_H.n54 11.6805
R606 CLKN_H.n37 CLKN_H.n36 11.6805
R607 CLKN_H.n38 CLKN_H.n37 11.6805
R608 CLKN_H.n39 CLKN_H.n38 11.6805
R609 CLKN_H.n40 CLKN_H.n39 11.6805
R610 CLKN_H.n41 CLKN_H.n40 11.6805
R611 CLKN_H.n55 CLKN_H.n41 11.6805
R612 CLKN_H.n53 CLKN_H.n42 11.6805
R613 CLKN_H.n49 CLKN_H.n42 11.6805
R614 CLKN_H.n49 CLKN_H.n48 11.6805
R615 CLKN_H.n48 CLKN_H.n47 11.6805
R616 CLKN_H.n47 CLKN_H.n44 11.6805
R617 CLKN_H.n25 CLKN_H.n24 11.6805
R618 CLKN_H.n26 CLKN_H.n25 11.6805
R619 CLKN_H.n8 CLKN_H.n7 11.6805
R620 CLKN_H.n9 CLKN_H.n8 11.6805
R621 CLKN_H.n10 CLKN_H.n9 11.6805
R622 CLKN_H.n11 CLKN_H.n10 11.6805
R623 CLKN_H.n12 CLKN_H.n11 11.6805
R624 CLKN_H.n26 CLKN_H.n12 11.6805
R625 CLKN_H.n24 CLKN_H.n13 11.6805
R626 CLKN_H.n20 CLKN_H.n13 11.6805
R627 CLKN_H.n20 CLKN_H.n19 11.6805
R628 CLKN_H.n19 CLKN_H.n18 11.6805
R629 CLKN_H.n18 CLKN_H.n15 11.6805
R630 CLKN_H.n66 CLKN_H.n65 11.6805
R631 CLKN_H.n61 CLKN_H.n60 11.6805
R632 CLKN_H.n58 CLKN_H.n28 10.9291
R633 CLKN_H.n69 CLKN_H.n63 10.9291
R634 CLKN_H.n58 CLKN_H.n57 9.0005
R635 CLKN_H.n69 CLKN_H.n68 9.0005
R636 CLKN_H.n46 CLKN_H.n45 7.17687
R637 CLKN_H.n35 CLKN_H.n34 7.17687
R638 CLKN_H.n17 CLKN_H.n16 7.17687
R639 CLKN_H.n6 CLKN_H.n5 7.17687
R640 CLKN_H.n68 CLKN_H.n64 7.10487
R641 CLKN_H.n68 CLKN_H.n67 7.10487
R642 CLKN_H.n63 CLKN_H.n59 7.10487
R643 CLKN_H.n63 CLKN_H.n62 7.10487
R644 CLKN_H.n36 CLKN_H.n35 4.42851
R645 CLKN_H.n45 CLKN_H.n44 4.42851
R646 CLKN_H.n7 CLKN_H.n6 4.42851
R647 CLKN_H.n16 CLKN_H.n15 4.42851
R648 CLKN_H.n65 CLKN_H.n64 4.42851
R649 CLKN_H.n67 CLKN_H.n66 4.42851
R650 CLKN_H.n60 CLKN_H.n59 4.42851
R651 CLKN_H.n62 CLKN_H.n61 4.42851
R652 CLKN_H CLKN_H.n70 0.714184
R653 CLKN_H.n52 CLKN_H.n29 0.1205
R654 CLKN_H.n52 CLKN_H.n51 0.1205
R655 CLKN_H.n51 CLKN_H.n50 0.1205
R656 CLKN_H.n50 CLKN_H.n43 0.1205
R657 CLKN_H.n46 CLKN_H.n43 0.1205
R658 CLKN_H.n34 CLKN_H.n33 0.1205
R659 CLKN_H.n33 CLKN_H.n32 0.1205
R660 CLKN_H.n32 CLKN_H.n31 0.1205
R661 CLKN_H.n31 CLKN_H.n30 0.1205
R662 CLKN_H.n56 CLKN_H.n30 0.1205
R663 CLKN_H.n23 CLKN_H.n0 0.1205
R664 CLKN_H.n23 CLKN_H.n22 0.1205
R665 CLKN_H.n22 CLKN_H.n21 0.1205
R666 CLKN_H.n21 CLKN_H.n14 0.1205
R667 CLKN_H.n17 CLKN_H.n14 0.1205
R668 CLKN_H.n5 CLKN_H.n4 0.1205
R669 CLKN_H.n4 CLKN_H.n3 0.1205
R670 CLKN_H.n3 CLKN_H.n2 0.1205
R671 CLKN_H.n2 CLKN_H.n1 0.1205
R672 CLKN_H.n27 CLKN_H.n1 0.1205
R673 CLKN_H.n57 CLKN_H.n29 0.0485
R674 CLKN_H.n57 CLKN_H.n56 0.0485
R675 CLKN_H.n28 CLKN_H.n0 0.0485
R676 CLKN_H.n28 CLKN_H.n27 0.0485
R677 CLKN_HB.n8 CLKN_HB.t3 113.632
R678 CLKN_HB.n5 CLKN_HB.t0 113.632
R679 CLKN_HB.n0 CLKN_HB.t4 113.632
R680 CLKN_HB.n3 CLKN_HB.t7 113.632
R681 CLKN_HB.n6 CLKN_HB.t1 109.174
R682 CLKN_HB.n7 CLKN_HB.t2 109.174
R683 CLKN_HB.n1 CLKN_HB.t5 109.174
R684 CLKN_HB.n2 CLKN_HB.t6 109.174
R685 CLKN_HB CLKN_HB.n10 13.6326
R686 CLKN_HB.n7 CLKN_HB.n6 11.6805
R687 CLKN_HB.n2 CLKN_HB.n1 11.6805
R688 CLKN_HB.n10 CLKN_HB.n4 10.9291
R689 CLKN_HB.n10 CLKN_HB.n9 9.0005
R690 CLKN_HB.n9 CLKN_HB.n5 7.10487
R691 CLKN_HB.n9 CLKN_HB.n8 7.10487
R692 CLKN_HB.n4 CLKN_HB.n0 7.10487
R693 CLKN_HB.n4 CLKN_HB.n3 7.10487
R694 CLKN_HB.n6 CLKN_HB.n5 4.42851
R695 CLKN_HB.n8 CLKN_HB.n7 4.42851
R696 CLKN_HB.n1 CLKN_HB.n0 4.42851
R697 CLKN_HB.n3 CLKN_HB.n2 4.42851
R698 VDD.t38 VDD.n129 651.841
R699 VDD.t104 VDD.n45 651.841
R700 VDD.t166 VDD.t208 450.829
R701 VDD.t176 VDD.t174 450.829
R702 VDD.t46 VDD.t200 450.829
R703 VDD.t44 VDD.t6 450.829
R704 VDD.t216 VDD.t154 450.829
R705 VDD.t226 VDD.t224 450.829
R706 VDD.t254 VDD.t248 450.829
R707 VDD.t84 VDD.t272 450.829
R708 VDD.t206 VDD.n85 417.582
R709 VDD.t158 VDD.n1 417.582
R710 VDD.n130 VDD.t14 338.123
R711 VDD.n46 VDD.t118 338.123
R712 VDD.n130 VDD.t120 112.707
R713 VDD.n46 VDD.t74 112.707
R714 VDD.t204 VDD.t206 44.1994
R715 VDD.t202 VDD.t204 44.1994
R716 VDD.t208 VDD.t202 44.1994
R717 VDD.t170 VDD.t166 44.1994
R718 VDD.t172 VDD.t170 44.1994
R719 VDD.t174 VDD.t172 44.1994
R720 VDD.t168 VDD.t176 44.1994
R721 VDD.t178 VDD.t168 44.1994
R722 VDD.t164 VDD.t178 44.1994
R723 VDD.t180 VDD.t164 44.1994
R724 VDD.t182 VDD.t180 44.1994
R725 VDD.t184 VDD.t182 44.1994
R726 VDD.t186 VDD.t184 44.1994
R727 VDD.t188 VDD.t186 44.1994
R728 VDD.t190 VDD.t188 44.1994
R729 VDD.t162 VDD.t190 44.1994
R730 VDD.t194 VDD.t162 44.1994
R731 VDD.t196 VDD.t194 44.1994
R732 VDD.t192 VDD.t196 44.1994
R733 VDD.t198 VDD.t192 44.1994
R734 VDD.t200 VDD.t198 44.1994
R735 VDD.t112 VDD.t46 44.1994
R736 VDD.t110 VDD.t112 44.1994
R737 VDD.t58 VDD.t110 44.1994
R738 VDD.t56 VDD.t58 44.1994
R739 VDD.t18 VDD.t56 44.1994
R740 VDD.t16 VDD.t18 44.1994
R741 VDD.t120 VDD.t16 44.1994
R742 VDD.t14 VDD.t88 44.1994
R743 VDD.t88 VDD.t86 44.1994
R744 VDD.t86 VDD.t286 44.1994
R745 VDD.t286 VDD.t284 44.1994
R746 VDD.t284 VDD.t70 44.1994
R747 VDD.t70 VDD.t68 44.1994
R748 VDD.t68 VDD.t44 44.1994
R749 VDD.t6 VDD.t28 44.1994
R750 VDD.t28 VDD.t92 44.1994
R751 VDD.t92 VDD.t50 44.1994
R752 VDD.t50 VDD.t8 44.1994
R753 VDD.t8 VDD.t30 44.1994
R754 VDD.t30 VDD.t94 44.1994
R755 VDD.t94 VDD.t126 44.1994
R756 VDD.t126 VDD.t264 44.1994
R757 VDD.t264 VDD.t132 44.1994
R758 VDD.t132 VDD.t140 44.1994
R759 VDD.t140 VDD.t108 44.1994
R760 VDD.t108 VDD.t146 44.1994
R761 VDD.t146 VDD.t266 44.1994
R762 VDD.t266 VDD.t134 44.1994
R763 VDD.t134 VDD.t52 44.1994
R764 VDD.t52 VDD.t10 44.1994
R765 VDD.t10 VDD.t142 44.1994
R766 VDD.t142 VDD.t32 44.1994
R767 VDD.t32 VDD.t96 44.1994
R768 VDD.t96 VDD.t116 44.1994
R769 VDD.t116 VDD.t148 44.1994
R770 VDD.t148 VDD.t256 44.1994
R771 VDD.t256 VDD.t34 44.1994
R772 VDD.t34 VDD.t98 44.1994
R773 VDD.t98 VDD.t268 44.1994
R774 VDD.t268 VDD.t152 44.1994
R775 VDD.t152 VDD.t36 44.1994
R776 VDD.t36 VDD.t100 44.1994
R777 VDD.t100 VDD.t54 44.1994
R778 VDD.t54 VDD.t12 44.1994
R779 VDD.t12 VDD.t38 44.1994
R780 VDD.t156 VDD.t158 44.1994
R781 VDD.t160 VDD.t156 44.1994
R782 VDD.t154 VDD.t160 44.1994
R783 VDD.t218 VDD.t216 44.1994
R784 VDD.t222 VDD.t218 44.1994
R785 VDD.t224 VDD.t222 44.1994
R786 VDD.t228 VDD.t226 44.1994
R787 VDD.t230 VDD.t228 44.1994
R788 VDD.t210 VDD.t230 44.1994
R789 VDD.t232 VDD.t210 44.1994
R790 VDD.t234 VDD.t232 44.1994
R791 VDD.t236 VDD.t234 44.1994
R792 VDD.t238 VDD.t236 44.1994
R793 VDD.t240 VDD.t238 44.1994
R794 VDD.t242 VDD.t240 44.1994
R795 VDD.t220 VDD.t242 44.1994
R796 VDD.t212 VDD.t220 44.1994
R797 VDD.t214 VDD.t212 44.1994
R798 VDD.t244 VDD.t214 44.1994
R799 VDD.t246 VDD.t244 44.1994
R800 VDD.t248 VDD.t246 44.1994
R801 VDD.t252 VDD.t254 44.1994
R802 VDD.t48 VDD.t252 44.1994
R803 VDD.t20 VDD.t48 44.1994
R804 VDD.t114 VDD.t20 44.1994
R805 VDD.t72 VDD.t114 44.1994
R806 VDD.t90 VDD.t72 44.1994
R807 VDD.t74 VDD.t90 44.1994
R808 VDD.t118 VDD.t270 44.1994
R809 VDD.t270 VDD.t258 44.1994
R810 VDD.t258 VDD.t82 44.1994
R811 VDD.t82 VDD.t40 44.1994
R812 VDD.t40 VDD.t42 44.1994
R813 VDD.t42 VDD.t66 44.1994
R814 VDD.t66 VDD.t84 44.1994
R815 VDD.t272 VDD.t250 44.1994
R816 VDD.t250 VDD.t274 44.1994
R817 VDD.t274 VDD.t276 44.1994
R818 VDD.t276 VDD.t278 44.1994
R819 VDD.t278 VDD.t150 44.1994
R820 VDD.t150 VDD.t0 44.1994
R821 VDD.t0 VDD.t76 44.1994
R822 VDD.t76 VDD.t60 44.1994
R823 VDD.t60 VDD.t22 44.1994
R824 VDD.t22 VDD.t122 44.1994
R825 VDD.t122 VDD.t2 44.1994
R826 VDD.t2 VDD.t78 44.1994
R827 VDD.t78 VDD.t62 44.1994
R828 VDD.t62 VDD.t24 44.1994
R829 VDD.t24 VDD.t124 44.1994
R830 VDD.t124 VDD.t260 44.1994
R831 VDD.t260 VDD.t128 44.1994
R832 VDD.t128 VDD.t4 44.1994
R833 VDD.t4 VDD.t136 44.1994
R834 VDD.t136 VDD.t80 44.1994
R835 VDD.t80 VDD.t280 44.1994
R836 VDD.t280 VDD.t64 44.1994
R837 VDD.t64 VDD.t26 44.1994
R838 VDD.t26 VDD.t102 44.1994
R839 VDD.t102 VDD.t106 44.1994
R840 VDD.t106 VDD.t144 44.1994
R841 VDD.t144 VDD.t262 44.1994
R842 VDD.t262 VDD.t130 44.1994
R843 VDD.t130 VDD.t138 44.1994
R844 VDD.t138 VDD.t282 44.1994
R845 VDD.t282 VDD.t104 44.1994
R846 VDD.n131 VDD.n130 26.4219
R847 VDD.n47 VDD.n46 26.4219
R848 VDD.n128 VDD.n127 11.1661
R849 VDD.n96 VDD.n95 11.1661
R850 VDD.n156 VDD.n155 11.1661
R851 VDD.n160 VDD.n159 11.1661
R852 VDD.n164 VDD.n163 11.1661
R853 VDD.n44 VDD.n43 11.1661
R854 VDD.n12 VDD.n11 11.1661
R855 VDD.n72 VDD.n71 11.1661
R856 VDD.n76 VDD.n75 11.1661
R857 VDD.n80 VDD.n79 11.1661
R858 VDD.n140 VDD.n139 11.1187
R859 VDD.n56 VDD.n55 11.1187
R860 VDD.n99 VDD.n97 5.51014
R861 VDD.n91 VDD.n89 5.51014
R862 VDD.n135 VDD.n133 5.51014
R863 VDD.n143 VDD.n141 5.51014
R864 VDD.n159 VDD.n157 5.51014
R865 VDD.n163 VDD.n161 5.51014
R866 VDD.n15 VDD.n13 5.51014
R867 VDD.n7 VDD.n5 5.51014
R868 VDD.n51 VDD.n49 5.51014
R869 VDD.n59 VDD.n57 5.51014
R870 VDD.n75 VDD.n73 5.51014
R871 VDD.n79 VDD.n77 5.51014
R872 VDD.n127 VDD.n126 5.32067
R873 VDD.n125 VDD.n124 5.32067
R874 VDD.n123 VDD.n122 5.32067
R875 VDD.n121 VDD.n120 5.32067
R876 VDD.n119 VDD.n118 5.32067
R877 VDD.n117 VDD.n116 5.32067
R878 VDD.n115 VDD.n114 5.32067
R879 VDD.n113 VDD.n112 5.32067
R880 VDD.n111 VDD.n110 5.32067
R881 VDD.n109 VDD.n108 5.32067
R882 VDD.n107 VDD.n106 5.32067
R883 VDD.n105 VDD.n104 5.32067
R884 VDD.n103 VDD.n102 5.32067
R885 VDD.n101 VDD.n100 5.32067
R886 VDD.n99 VDD.n98 5.32067
R887 VDD.n95 VDD.n94 5.32067
R888 VDD.n93 VDD.n92 5.32067
R889 VDD.n91 VDD.n90 5.32067
R890 VDD.n139 VDD.n138 5.32067
R891 VDD.n137 VDD.n136 5.32067
R892 VDD.n135 VDD.n134 5.32067
R893 VDD.n155 VDD.n154 5.32067
R894 VDD.n153 VDD.n152 5.32067
R895 VDD.n151 VDD.n150 5.32067
R896 VDD.n149 VDD.n148 5.32067
R897 VDD.n147 VDD.n146 5.32067
R898 VDD.n145 VDD.n144 5.32067
R899 VDD.n143 VDD.n142 5.32067
R900 VDD.n159 VDD.n158 5.32067
R901 VDD.n163 VDD.n162 5.32067
R902 VDD.n43 VDD.n42 5.32067
R903 VDD.n41 VDD.n40 5.32067
R904 VDD.n39 VDD.n38 5.32067
R905 VDD.n37 VDD.n36 5.32067
R906 VDD.n35 VDD.n34 5.32067
R907 VDD.n33 VDD.n32 5.32067
R908 VDD.n31 VDD.n30 5.32067
R909 VDD.n29 VDD.n28 5.32067
R910 VDD.n27 VDD.n26 5.32067
R911 VDD.n25 VDD.n24 5.32067
R912 VDD.n23 VDD.n22 5.32067
R913 VDD.n21 VDD.n20 5.32067
R914 VDD.n19 VDD.n18 5.32067
R915 VDD.n17 VDD.n16 5.32067
R916 VDD.n15 VDD.n14 5.32067
R917 VDD.n11 VDD.n10 5.32067
R918 VDD.n9 VDD.n8 5.32067
R919 VDD.n7 VDD.n6 5.32067
R920 VDD.n55 VDD.n54 5.32067
R921 VDD.n53 VDD.n52 5.32067
R922 VDD.n51 VDD.n50 5.32067
R923 VDD.n71 VDD.n70 5.32067
R924 VDD.n69 VDD.n68 5.32067
R925 VDD.n67 VDD.n66 5.32067
R926 VDD.n65 VDD.n64 5.32067
R927 VDD.n63 VDD.n62 5.32067
R928 VDD.n61 VDD.n60 5.32067
R929 VDD.n59 VDD.n58 5.32067
R930 VDD.n75 VDD.n74 5.32067
R931 VDD.n79 VDD.n78 5.32067
R932 VDD.n84 VDD.n0 4.5005
R933 VDD.n168 VDD.n0 4.5005
R934 VDD.n84 VDD.n83 3.31026
R935 VDD.n168 VDD.n167 2.76928
R936 VDD.n170 VDD.n169 2.26839
R937 VDD.n167 VDD.n166 2.2545
R938 VDD.n83 VDD.n82 2.2545
R939 VDD.n166 VDD.n165 2.2505
R940 VDD.n132 VDD.n86 2.2505
R941 VDD.n88 VDD.n87 2.2505
R942 VDD.n82 VDD.n81 2.2505
R943 VDD.n48 VDD.n2 2.2505
R944 VDD.n4 VDD.n3 2.2505
R945 VDD.n129 VDD.n88 1.49652
R946 VDD.n45 VDD.n4 1.49652
R947 VDD VDD.n170 1.13544
R948 VDD.n128 VDD.n96 0.7421
R949 VDD.n44 VDD.n12 0.7421
R950 VDD.n160 VDD.n156 0.4541
R951 VDD.n76 VDD.n72 0.4541
R952 VDD.n166 VDD.n86 0.369833
R953 VDD.n82 VDD.n2 0.369833
R954 VDD.n156 VDD.n140 0.3011
R955 VDD.n72 VDD.n56 0.3011
R956 VDD.n96 VDD.n87 0.287375
R957 VDD.n12 VDD.n3 0.287375
R958 VDD.n164 VDD.n160 0.2381
R959 VDD.n80 VDD.n76 0.2381
R960 VDD.n165 VDD.n164 0.236975
R961 VDD.n81 VDD.n80 0.236975
R962 VDD.n126 VDD.t13 0.228
R963 VDD.n126 VDD.t39 0.228
R964 VDD.n124 VDD.t101 0.228
R965 VDD.n124 VDD.t55 0.228
R966 VDD.n122 VDD.t153 0.228
R967 VDD.n122 VDD.t37 0.228
R968 VDD.n120 VDD.t99 0.228
R969 VDD.n120 VDD.t269 0.228
R970 VDD.n118 VDD.t257 0.228
R971 VDD.n118 VDD.t35 0.228
R972 VDD.n116 VDD.t117 0.228
R973 VDD.n116 VDD.t149 0.228
R974 VDD.n114 VDD.t33 0.228
R975 VDD.n114 VDD.t97 0.228
R976 VDD.n112 VDD.t11 0.228
R977 VDD.n112 VDD.t143 0.228
R978 VDD.n110 VDD.t135 0.228
R979 VDD.n110 VDD.t53 0.228
R980 VDD.n108 VDD.t147 0.228
R981 VDD.n108 VDD.t267 0.228
R982 VDD.n106 VDD.t141 0.228
R983 VDD.n106 VDD.t109 0.228
R984 VDD.n104 VDD.t265 0.228
R985 VDD.n104 VDD.t133 0.228
R986 VDD.n102 VDD.t95 0.228
R987 VDD.n102 VDD.t127 0.228
R988 VDD.n100 VDD.t9 0.228
R989 VDD.n100 VDD.t31 0.228
R990 VDD.n98 VDD.t93 0.228
R991 VDD.n98 VDD.t51 0.228
R992 VDD.n97 VDD.t7 0.228
R993 VDD.n97 VDD.t29 0.228
R994 VDD.n94 VDD.t69 0.228
R995 VDD.n94 VDD.t45 0.228
R996 VDD.n92 VDD.t285 0.228
R997 VDD.n92 VDD.t71 0.228
R998 VDD.n90 VDD.t87 0.228
R999 VDD.n90 VDD.t287 0.228
R1000 VDD.n89 VDD.t15 0.228
R1001 VDD.n89 VDD.t89 0.228
R1002 VDD.n138 VDD.t17 0.228
R1003 VDD.n138 VDD.t121 0.228
R1004 VDD.n136 VDD.t57 0.228
R1005 VDD.n136 VDD.t19 0.228
R1006 VDD.n134 VDD.t111 0.228
R1007 VDD.n134 VDD.t59 0.228
R1008 VDD.n133 VDD.t47 0.228
R1009 VDD.n133 VDD.t113 0.228
R1010 VDD.n154 VDD.t199 0.228
R1011 VDD.n154 VDD.t201 0.228
R1012 VDD.n152 VDD.t197 0.228
R1013 VDD.n152 VDD.t193 0.228
R1014 VDD.n150 VDD.t163 0.228
R1015 VDD.n150 VDD.t195 0.228
R1016 VDD.n148 VDD.t189 0.228
R1017 VDD.n148 VDD.t191 0.228
R1018 VDD.n146 VDD.t185 0.228
R1019 VDD.n146 VDD.t187 0.228
R1020 VDD.n144 VDD.t181 0.228
R1021 VDD.n144 VDD.t183 0.228
R1022 VDD.n142 VDD.t179 0.228
R1023 VDD.n142 VDD.t165 0.228
R1024 VDD.n141 VDD.t177 0.228
R1025 VDD.n141 VDD.t169 0.228
R1026 VDD.n158 VDD.t173 0.228
R1027 VDD.n158 VDD.t175 0.228
R1028 VDD.n157 VDD.t167 0.228
R1029 VDD.n157 VDD.t171 0.228
R1030 VDD.n162 VDD.t203 0.228
R1031 VDD.n162 VDD.t209 0.228
R1032 VDD.n161 VDD.t207 0.228
R1033 VDD.n161 VDD.t205 0.228
R1034 VDD.n42 VDD.t283 0.228
R1035 VDD.n42 VDD.t105 0.228
R1036 VDD.n40 VDD.t131 0.228
R1037 VDD.n40 VDD.t139 0.228
R1038 VDD.n38 VDD.t145 0.228
R1039 VDD.n38 VDD.t263 0.228
R1040 VDD.n36 VDD.t103 0.228
R1041 VDD.n36 VDD.t107 0.228
R1042 VDD.n34 VDD.t65 0.228
R1043 VDD.n34 VDD.t27 0.228
R1044 VDD.n32 VDD.t81 0.228
R1045 VDD.n32 VDD.t281 0.228
R1046 VDD.n30 VDD.t5 0.228
R1047 VDD.n30 VDD.t137 0.228
R1048 VDD.n28 VDD.t261 0.228
R1049 VDD.n28 VDD.t129 0.228
R1050 VDD.n26 VDD.t25 0.228
R1051 VDD.n26 VDD.t125 0.228
R1052 VDD.n24 VDD.t79 0.228
R1053 VDD.n24 VDD.t63 0.228
R1054 VDD.n22 VDD.t123 0.228
R1055 VDD.n22 VDD.t3 0.228
R1056 VDD.n20 VDD.t61 0.228
R1057 VDD.n20 VDD.t23 0.228
R1058 VDD.n18 VDD.t1 0.228
R1059 VDD.n18 VDD.t77 0.228
R1060 VDD.n16 VDD.t279 0.228
R1061 VDD.n16 VDD.t151 0.228
R1062 VDD.n14 VDD.t275 0.228
R1063 VDD.n14 VDD.t277 0.228
R1064 VDD.n13 VDD.t273 0.228
R1065 VDD.n13 VDD.t251 0.228
R1066 VDD.n10 VDD.t67 0.228
R1067 VDD.n10 VDD.t85 0.228
R1068 VDD.n8 VDD.t41 0.228
R1069 VDD.n8 VDD.t43 0.228
R1070 VDD.n6 VDD.t259 0.228
R1071 VDD.n6 VDD.t83 0.228
R1072 VDD.n5 VDD.t119 0.228
R1073 VDD.n5 VDD.t271 0.228
R1074 VDD.n54 VDD.t91 0.228
R1075 VDD.n54 VDD.t75 0.228
R1076 VDD.n52 VDD.t115 0.228
R1077 VDD.n52 VDD.t73 0.228
R1078 VDD.n50 VDD.t49 0.228
R1079 VDD.n50 VDD.t21 0.228
R1080 VDD.n49 VDD.t255 0.228
R1081 VDD.n49 VDD.t253 0.228
R1082 VDD.n70 VDD.t247 0.228
R1083 VDD.n70 VDD.t249 0.228
R1084 VDD.n68 VDD.t215 0.228
R1085 VDD.n68 VDD.t245 0.228
R1086 VDD.n66 VDD.t221 0.228
R1087 VDD.n66 VDD.t213 0.228
R1088 VDD.n64 VDD.t241 0.228
R1089 VDD.n64 VDD.t243 0.228
R1090 VDD.n62 VDD.t237 0.228
R1091 VDD.n62 VDD.t239 0.228
R1092 VDD.n60 VDD.t233 0.228
R1093 VDD.n60 VDD.t235 0.228
R1094 VDD.n58 VDD.t231 0.228
R1095 VDD.n58 VDD.t211 0.228
R1096 VDD.n57 VDD.t227 0.228
R1097 VDD.n57 VDD.t229 0.228
R1098 VDD.n74 VDD.t223 0.228
R1099 VDD.n74 VDD.t225 0.228
R1100 VDD.n73 VDD.t217 0.228
R1101 VDD.n73 VDD.t219 0.228
R1102 VDD.n78 VDD.t161 0.228
R1103 VDD.n78 VDD.t155 0.228
R1104 VDD.n77 VDD.t159 0.228
R1105 VDD.n77 VDD.t157 0.228
R1106 VDD.n129 VDD.n128 0.222761
R1107 VDD.n45 VDD.n44 0.222761
R1108 VDD.n101 VDD.n99 0.189974
R1109 VDD.n103 VDD.n101 0.189974
R1110 VDD.n105 VDD.n103 0.189974
R1111 VDD.n107 VDD.n105 0.189974
R1112 VDD.n109 VDD.n107 0.189974
R1113 VDD.n111 VDD.n109 0.189974
R1114 VDD.n113 VDD.n111 0.189974
R1115 VDD.n115 VDD.n113 0.189974
R1116 VDD.n117 VDD.n115 0.189974
R1117 VDD.n119 VDD.n117 0.189974
R1118 VDD.n121 VDD.n119 0.189974
R1119 VDD.n123 VDD.n121 0.189974
R1120 VDD.n125 VDD.n123 0.189974
R1121 VDD.n127 VDD.n125 0.189974
R1122 VDD.n93 VDD.n91 0.189974
R1123 VDD.n95 VDD.n93 0.189974
R1124 VDD.n137 VDD.n135 0.189974
R1125 VDD.n139 VDD.n137 0.189974
R1126 VDD.n145 VDD.n143 0.189974
R1127 VDD.n147 VDD.n145 0.189974
R1128 VDD.n149 VDD.n147 0.189974
R1129 VDD.n151 VDD.n149 0.189974
R1130 VDD.n153 VDD.n151 0.189974
R1131 VDD.n155 VDD.n153 0.189974
R1132 VDD.n17 VDD.n15 0.189974
R1133 VDD.n19 VDD.n17 0.189974
R1134 VDD.n21 VDD.n19 0.189974
R1135 VDD.n23 VDD.n21 0.189974
R1136 VDD.n25 VDD.n23 0.189974
R1137 VDD.n27 VDD.n25 0.189974
R1138 VDD.n29 VDD.n27 0.189974
R1139 VDD.n31 VDD.n29 0.189974
R1140 VDD.n33 VDD.n31 0.189974
R1141 VDD.n35 VDD.n33 0.189974
R1142 VDD.n37 VDD.n35 0.189974
R1143 VDD.n39 VDD.n37 0.189974
R1144 VDD.n41 VDD.n39 0.189974
R1145 VDD.n43 VDD.n41 0.189974
R1146 VDD.n9 VDD.n7 0.189974
R1147 VDD.n11 VDD.n9 0.189974
R1148 VDD.n53 VDD.n51 0.189974
R1149 VDD.n55 VDD.n53 0.189974
R1150 VDD.n61 VDD.n59 0.189974
R1151 VDD.n63 VDD.n61 0.189974
R1152 VDD.n65 VDD.n63 0.189974
R1153 VDD.n67 VDD.n65 0.189974
R1154 VDD.n69 VDD.n67 0.189974
R1155 VDD.n71 VDD.n69 0.189974
R1156 VDD.n170 VDD.n0 0.020105
R1157 VDD.n140 VDD.n132 0.018725
R1158 VDD.n56 VDD.n48 0.018725
R1159 VDD.n167 VDD.n85 0.00725
R1160 VDD.n165 VDD.n85 0.00725
R1161 VDD.n132 VDD.n131 0.00725
R1162 VDD.n131 VDD.n87 0.00725
R1163 VDD.n83 VDD.n1 0.00725
R1164 VDD.n81 VDD.n1 0.00725
R1165 VDD.n48 VDD.n47 0.00725
R1166 VDD.n47 VDD.n3 0.00725
R1167 VDD.n169 VDD.n168 0.0054955
R1168 VDD.n169 VDD.n84 0.0054955
R1169 VDD.n88 VDD.n86 0.0045
R1170 VDD.n4 VDD.n2 0.0045
R1171 VSS.n92 VSS.n91 5121.21
R1172 VSS.n177 VSS.n92 5121.21
R1173 VSS.n89 VSS.n88 4481.36
R1174 VSS.n178 VSS.n177 4318.79
R1175 VSS.n90 VSS.n89 3545.45
R1176 VSS.n91 VSS.n90 3545.45
R1177 VSS.t56 VSS.n49 2079.53
R1178 VSS.t84 VSS.n140 2079.53
R1179 VSS.t228 VSS.t174 1481.56
R1180 VSS.t236 VSS.t234 1481.56
R1181 VSS.t20 VSS.t262 1481.56
R1182 VSS.t112 VSS.t92 1481.56
R1183 VSS.t182 VSS.t222 1481.56
R1184 VSS.t198 VSS.t190 1481.56
R1185 VSS.t100 VSS.t214 1481.56
R1186 VSS.t286 VSS.t62 1481.56
R1187 VSS.t170 VSS.n4 1285.47
R1188 VSS.n176 VSS.t220 1285.47
R1189 VSS.n50 VSS.t32 1111.17
R1190 VSS.n141 VSS.t34 1111.17
R1191 VSS.n90 VSS.n3 933.894
R1192 VSS.n91 VSS.n2 933.894
R1193 VSS.n89 VSS.n4 907.822
R1194 VSS.n177 VSS.n176 907.822
R1195 VSS.n50 VSS.t18 370.392
R1196 VSS.n141 VSS.t90 370.392
R1197 VSS.n179 VSS.n92 351.623
R1198 VSS.t172 VSS.t170 145.251
R1199 VSS.t168 VSS.t172 145.251
R1200 VSS.t174 VSS.t168 145.251
R1201 VSS.t230 VSS.t228 145.251
R1202 VSS.t232 VSS.t230 145.251
R1203 VSS.t234 VSS.t232 145.251
R1204 VSS.t226 VSS.t236 145.251
R1205 VSS.t240 VSS.t226 145.251
R1206 VSS.t238 VSS.t240 145.251
R1207 VSS.t242 VSS.t238 145.251
R1208 VSS.t244 VSS.t242 145.251
R1209 VSS.t246 VSS.t244 145.251
R1210 VSS.t248 VSS.t246 145.251
R1211 VSS.t250 VSS.t248 145.251
R1212 VSS.t252 VSS.t250 145.251
R1213 VSS.t224 VSS.t252 145.251
R1214 VSS.t254 VSS.t224 145.251
R1215 VSS.t256 VSS.t254 145.251
R1216 VSS.t258 VSS.t256 145.251
R1217 VSS.t260 VSS.t258 145.251
R1218 VSS.t262 VSS.t260 145.251
R1219 VSS.t272 VSS.t20 145.251
R1220 VSS.t280 VSS.t272 145.251
R1221 VSS.t102 VSS.t280 145.251
R1222 VSS.t38 VSS.t102 145.251
R1223 VSS.t166 VSS.t38 145.251
R1224 VSS.t164 VSS.t166 145.251
R1225 VSS.t18 VSS.t164 145.251
R1226 VSS.t32 VSS.t278 145.251
R1227 VSS.t278 VSS.t12 145.251
R1228 VSS.t12 VSS.t58 145.251
R1229 VSS.t58 VSS.t60 145.251
R1230 VSS.t60 VSS.t150 145.251
R1231 VSS.t150 VSS.t270 145.251
R1232 VSS.t270 VSS.t112 145.251
R1233 VSS.t92 VSS.t110 145.251
R1234 VSS.t110 VSS.t264 145.251
R1235 VSS.t264 VSS.t0 145.251
R1236 VSS.t0 VSS.t50 145.251
R1237 VSS.t50 VSS.t284 145.251
R1238 VSS.t284 VSS.t282 145.251
R1239 VSS.t282 VSS.t76 145.251
R1240 VSS.t76 VSS.t74 145.251
R1241 VSS.t74 VSS.t276 145.251
R1242 VSS.t276 VSS.t274 145.251
R1243 VSS.t274 VSS.t80 145.251
R1244 VSS.t80 VSS.t78 145.251
R1245 VSS.t78 VSS.t148 145.251
R1246 VSS.t148 VSS.t146 145.251
R1247 VSS.t146 VSS.t134 145.251
R1248 VSS.t134 VSS.t132 145.251
R1249 VSS.t132 VSS.t138 145.251
R1250 VSS.t138 VSS.t136 145.251
R1251 VSS.t136 VSS.t4 145.251
R1252 VSS.t4 VSS.t2 145.251
R1253 VSS.t2 VSS.t54 145.251
R1254 VSS.t54 VSS.t52 145.251
R1255 VSS.t52 VSS.t48 145.251
R1256 VSS.t48 VSS.t46 145.251
R1257 VSS.t46 VSS.t24 145.251
R1258 VSS.t24 VSS.t22 145.251
R1259 VSS.t22 VSS.t106 145.251
R1260 VSS.t106 VSS.t104 145.251
R1261 VSS.t104 VSS.t8 145.251
R1262 VSS.t8 VSS.t6 145.251
R1263 VSS.t6 VSS.t56 145.251
R1264 VSS.t218 VSS.t220 145.251
R1265 VSS.t216 VSS.t218 145.251
R1266 VSS.t222 VSS.t216 145.251
R1267 VSS.t184 VSS.t182 145.251
R1268 VSS.t188 VSS.t184 145.251
R1269 VSS.t190 VSS.t188 145.251
R1270 VSS.t194 VSS.t198 145.251
R1271 VSS.t180 VSS.t194 145.251
R1272 VSS.t186 VSS.t180 145.251
R1273 VSS.t178 VSS.t186 145.251
R1274 VSS.t200 VSS.t178 145.251
R1275 VSS.t202 VSS.t200 145.251
R1276 VSS.t204 VSS.t202 145.251
R1277 VSS.t206 VSS.t204 145.251
R1278 VSS.t208 VSS.t206 145.251
R1279 VSS.t196 VSS.t208 145.251
R1280 VSS.t176 VSS.t196 145.251
R1281 VSS.t192 VSS.t176 145.251
R1282 VSS.t210 VSS.t192 145.251
R1283 VSS.t212 VSS.t210 145.251
R1284 VSS.t214 VSS.t212 145.251
R1285 VSS.t44 VSS.t100 145.251
R1286 VSS.t42 VSS.t44 145.251
R1287 VSS.t16 VSS.t42 145.251
R1288 VSS.t14 VSS.t16 145.251
R1289 VSS.t152 VSS.t14 145.251
R1290 VSS.t36 VSS.t152 145.251
R1291 VSS.t90 VSS.t36 145.251
R1292 VSS.t34 VSS.t88 145.251
R1293 VSS.t88 VSS.t86 145.251
R1294 VSS.t86 VSS.t144 145.251
R1295 VSS.t144 VSS.t142 145.251
R1296 VSS.t142 VSS.t98 145.251
R1297 VSS.t98 VSS.t96 145.251
R1298 VSS.t96 VSS.t286 145.251
R1299 VSS.t62 VSS.t108 145.251
R1300 VSS.t108 VSS.t70 145.251
R1301 VSS.t70 VSS.t40 145.251
R1302 VSS.t40 VSS.t10 145.251
R1303 VSS.t10 VSS.t26 145.251
R1304 VSS.t26 VSS.t64 145.251
R1305 VSS.t64 VSS.t82 145.251
R1306 VSS.t82 VSS.t72 145.251
R1307 VSS.t72 VSS.t94 145.251
R1308 VSS.t94 VSS.t114 145.251
R1309 VSS.t114 VSS.t122 145.251
R1310 VSS.t122 VSS.t154 145.251
R1311 VSS.t154 VSS.t140 145.251
R1312 VSS.t140 VSS.t116 145.251
R1313 VSS.t116 VSS.t126 145.251
R1314 VSS.t126 VSS.t124 145.251
R1315 VSS.t124 VSS.t158 145.251
R1316 VSS.t158 VSS.t156 145.251
R1317 VSS.t156 VSS.t120 145.251
R1318 VSS.t120 VSS.t118 145.251
R1319 VSS.t118 VSS.t130 145.251
R1320 VSS.t130 VSS.t128 145.251
R1321 VSS.t128 VSS.t162 145.251
R1322 VSS.t162 VSS.t160 145.251
R1323 VSS.t160 VSS.t268 145.251
R1324 VSS.t268 VSS.t266 145.251
R1325 VSS.t266 VSS.t30 145.251
R1326 VSS.t30 VSS.t28 145.251
R1327 VSS.t28 VSS.t68 145.251
R1328 VSS.t68 VSS.t66 145.251
R1329 VSS.t66 VSS.t84 145.251
R1330 VSS.n5 VSS.n4 24.2219
R1331 VSS.n51 VSS.n50 24.2219
R1332 VSS.n176 VSS.n175 24.2219
R1333 VSS.n142 VSS.n141 24.2219
R1334 VSS.n48 VSS.n47 9.9768
R1335 VSS.n16 VSS.n15 9.9768
R1336 VSS.n76 VSS.n75 9.9768
R1337 VSS.n80 VSS.n79 9.9768
R1338 VSS.n84 VSS.n83 9.9768
R1339 VSS.n139 VSS.n138 9.9768
R1340 VSS.n107 VSS.n106 9.9768
R1341 VSS.n162 VSS.n161 9.9768
R1342 VSS.n146 VSS.n145 9.9768
R1343 VSS.n97 VSS.n96 9.9768
R1344 VSS.n60 VSS.n59 9.92943
R1345 VSS.n170 VSS.n169 9.92943
R1346 VSS.n19 VSS.n17 5.57485
R1347 VSS.n11 VSS.n9 5.57485
R1348 VSS.n55 VSS.n53 5.57485
R1349 VSS.n63 VSS.n61 5.57485
R1350 VSS.n79 VSS.n77 5.57485
R1351 VSS.n83 VSS.n81 5.57485
R1352 VSS.n110 VSS.n108 5.57485
R1353 VSS.n102 VSS.n100 5.57485
R1354 VSS.n165 VSS.n163 5.57485
R1355 VSS.n149 VSS.n147 5.57485
R1356 VSS.n145 VSS.n143 5.57485
R1357 VSS.n96 VSS.n94 5.57485
R1358 VSS.n47 VSS.n46 5.38537
R1359 VSS.n45 VSS.n44 5.38537
R1360 VSS.n43 VSS.n42 5.38537
R1361 VSS.n41 VSS.n40 5.38537
R1362 VSS.n39 VSS.n38 5.38537
R1363 VSS.n37 VSS.n36 5.38537
R1364 VSS.n35 VSS.n34 5.38537
R1365 VSS.n33 VSS.n32 5.38537
R1366 VSS.n31 VSS.n30 5.38537
R1367 VSS.n29 VSS.n28 5.38537
R1368 VSS.n27 VSS.n26 5.38537
R1369 VSS.n25 VSS.n24 5.38537
R1370 VSS.n23 VSS.n22 5.38537
R1371 VSS.n21 VSS.n20 5.38537
R1372 VSS.n19 VSS.n18 5.38537
R1373 VSS.n15 VSS.n14 5.38537
R1374 VSS.n13 VSS.n12 5.38537
R1375 VSS.n11 VSS.n10 5.38537
R1376 VSS.n59 VSS.n58 5.38537
R1377 VSS.n57 VSS.n56 5.38537
R1378 VSS.n55 VSS.n54 5.38537
R1379 VSS.n75 VSS.n74 5.38537
R1380 VSS.n73 VSS.n72 5.38537
R1381 VSS.n71 VSS.n70 5.38537
R1382 VSS.n69 VSS.n68 5.38537
R1383 VSS.n67 VSS.n66 5.38537
R1384 VSS.n65 VSS.n64 5.38537
R1385 VSS.n63 VSS.n62 5.38537
R1386 VSS.n79 VSS.n78 5.38537
R1387 VSS.n83 VSS.n82 5.38537
R1388 VSS.n138 VSS.n137 5.38537
R1389 VSS.n136 VSS.n135 5.38537
R1390 VSS.n134 VSS.n133 5.38537
R1391 VSS.n132 VSS.n131 5.38537
R1392 VSS.n130 VSS.n129 5.38537
R1393 VSS.n128 VSS.n127 5.38537
R1394 VSS.n126 VSS.n125 5.38537
R1395 VSS.n124 VSS.n123 5.38537
R1396 VSS.n122 VSS.n121 5.38537
R1397 VSS.n120 VSS.n119 5.38537
R1398 VSS.n118 VSS.n117 5.38537
R1399 VSS.n116 VSS.n115 5.38537
R1400 VSS.n114 VSS.n113 5.38537
R1401 VSS.n112 VSS.n111 5.38537
R1402 VSS.n110 VSS.n109 5.38537
R1403 VSS.n106 VSS.n105 5.38537
R1404 VSS.n104 VSS.n103 5.38537
R1405 VSS.n102 VSS.n101 5.38537
R1406 VSS.n169 VSS.n168 5.38537
R1407 VSS.n167 VSS.n166 5.38537
R1408 VSS.n165 VSS.n164 5.38537
R1409 VSS.n161 VSS.n160 5.38537
R1410 VSS.n159 VSS.n158 5.38537
R1411 VSS.n157 VSS.n156 5.38537
R1412 VSS.n155 VSS.n154 5.38537
R1413 VSS.n153 VSS.n152 5.38537
R1414 VSS.n151 VSS.n150 5.38537
R1415 VSS.n149 VSS.n148 5.38537
R1416 VSS.n145 VSS.n144 5.38537
R1417 VSS.n96 VSS.n95 5.38537
R1418 VSS.n1 VSS.n0 4.5005
R1419 VSS.n180 VSS.n0 4.5005
R1420 VSS.n182 VSS.n181 2.26839
R1421 VSS.n87 VSS.n86 2.2545
R1422 VSS.n173 VSS.n93 2.2545
R1423 VSS.n86 VSS.n85 2.2505
R1424 VSS.n52 VSS.n6 2.2505
R1425 VSS.n8 VSS.n7 2.2505
R1426 VSS.n174 VSS.n173 2.2505
R1427 VSS.n172 VSS.n171 2.2505
R1428 VSS.n99 VSS.n98 2.2505
R1429 VSS.n88 VSS.n87 1.90124
R1430 VSS.n178 VSS.n93 1.90124
R1431 VSS.n49 VSS.n8 1.49652
R1432 VSS.n140 VSS.n98 1.49652
R1433 VSS VSS.n182 1.13544
R1434 VSS.n48 VSS.n16 0.7421
R1435 VSS.n139 VSS.n107 0.7421
R1436 VSS.n88 VSS.n3 0.543479
R1437 VSS.n3 VSS.n2 0.543479
R1438 VSS.n179 VSS.n178 0.543479
R1439 VSS.n2 VSS.n1 0.507615
R1440 VSS.n180 VSS.n179 0.507363
R1441 VSS.n80 VSS.n76 0.4541
R1442 VSS.n162 VSS.n146 0.4541
R1443 VSS.n86 VSS.n6 0.369833
R1444 VSS.n173 VSS.n172 0.369833
R1445 VSS.n76 VSS.n60 0.3011
R1446 VSS.n170 VSS.n162 0.3011
R1447 VSS.n16 VSS.n7 0.287375
R1448 VSS.n107 VSS.n99 0.287375
R1449 VSS.n84 VSS.n80 0.2381
R1450 VSS.n146 VSS.n97 0.2381
R1451 VSS.n85 VSS.n84 0.236975
R1452 VSS.n174 VSS.n97 0.236975
R1453 VSS.n49 VSS.n48 0.222761
R1454 VSS.n140 VSS.n139 0.222761
R1455 VSS.n46 VSS.t7 0.20525
R1456 VSS.n46 VSS.t57 0.20525
R1457 VSS.n44 VSS.t105 0.20525
R1458 VSS.n44 VSS.t9 0.20525
R1459 VSS.n42 VSS.t23 0.20525
R1460 VSS.n42 VSS.t107 0.20525
R1461 VSS.n40 VSS.t47 0.20525
R1462 VSS.n40 VSS.t25 0.20525
R1463 VSS.n38 VSS.t53 0.20525
R1464 VSS.n38 VSS.t49 0.20525
R1465 VSS.n36 VSS.t3 0.20525
R1466 VSS.n36 VSS.t55 0.20525
R1467 VSS.n34 VSS.t137 0.20525
R1468 VSS.n34 VSS.t5 0.20525
R1469 VSS.n32 VSS.t133 0.20525
R1470 VSS.n32 VSS.t139 0.20525
R1471 VSS.n30 VSS.t147 0.20525
R1472 VSS.n30 VSS.t135 0.20525
R1473 VSS.n28 VSS.t79 0.20525
R1474 VSS.n28 VSS.t149 0.20525
R1475 VSS.n26 VSS.t275 0.20525
R1476 VSS.n26 VSS.t81 0.20525
R1477 VSS.n24 VSS.t75 0.20525
R1478 VSS.n24 VSS.t277 0.20525
R1479 VSS.n22 VSS.t283 0.20525
R1480 VSS.n22 VSS.t77 0.20525
R1481 VSS.n20 VSS.t51 0.20525
R1482 VSS.n20 VSS.t285 0.20525
R1483 VSS.n18 VSS.t265 0.20525
R1484 VSS.n18 VSS.t1 0.20525
R1485 VSS.n17 VSS.t93 0.20525
R1486 VSS.n17 VSS.t111 0.20525
R1487 VSS.n14 VSS.t271 0.20525
R1488 VSS.n14 VSS.t113 0.20525
R1489 VSS.n12 VSS.t61 0.20525
R1490 VSS.n12 VSS.t151 0.20525
R1491 VSS.n10 VSS.t13 0.20525
R1492 VSS.n10 VSS.t59 0.20525
R1493 VSS.n9 VSS.t33 0.20525
R1494 VSS.n9 VSS.t279 0.20525
R1495 VSS.n58 VSS.t165 0.20525
R1496 VSS.n58 VSS.t19 0.20525
R1497 VSS.n56 VSS.t39 0.20525
R1498 VSS.n56 VSS.t167 0.20525
R1499 VSS.n54 VSS.t281 0.20525
R1500 VSS.n54 VSS.t103 0.20525
R1501 VSS.n53 VSS.t21 0.20525
R1502 VSS.n53 VSS.t273 0.20525
R1503 VSS.n74 VSS.t261 0.20525
R1504 VSS.n74 VSS.t263 0.20525
R1505 VSS.n72 VSS.t257 0.20525
R1506 VSS.n72 VSS.t259 0.20525
R1507 VSS.n70 VSS.t225 0.20525
R1508 VSS.n70 VSS.t255 0.20525
R1509 VSS.n68 VSS.t251 0.20525
R1510 VSS.n68 VSS.t253 0.20525
R1511 VSS.n66 VSS.t247 0.20525
R1512 VSS.n66 VSS.t249 0.20525
R1513 VSS.n64 VSS.t243 0.20525
R1514 VSS.n64 VSS.t245 0.20525
R1515 VSS.n62 VSS.t241 0.20525
R1516 VSS.n62 VSS.t239 0.20525
R1517 VSS.n61 VSS.t237 0.20525
R1518 VSS.n61 VSS.t227 0.20525
R1519 VSS.n78 VSS.t233 0.20525
R1520 VSS.n78 VSS.t235 0.20525
R1521 VSS.n77 VSS.t229 0.20525
R1522 VSS.n77 VSS.t231 0.20525
R1523 VSS.n82 VSS.t169 0.20525
R1524 VSS.n82 VSS.t175 0.20525
R1525 VSS.n81 VSS.t171 0.20525
R1526 VSS.n81 VSS.t173 0.20525
R1527 VSS.n137 VSS.t67 0.20525
R1528 VSS.n137 VSS.t85 0.20525
R1529 VSS.n135 VSS.t29 0.20525
R1530 VSS.n135 VSS.t69 0.20525
R1531 VSS.n133 VSS.t267 0.20525
R1532 VSS.n133 VSS.t31 0.20525
R1533 VSS.n131 VSS.t161 0.20525
R1534 VSS.n131 VSS.t269 0.20525
R1535 VSS.n129 VSS.t129 0.20525
R1536 VSS.n129 VSS.t163 0.20525
R1537 VSS.n127 VSS.t119 0.20525
R1538 VSS.n127 VSS.t131 0.20525
R1539 VSS.n125 VSS.t157 0.20525
R1540 VSS.n125 VSS.t121 0.20525
R1541 VSS.n123 VSS.t125 0.20525
R1542 VSS.n123 VSS.t159 0.20525
R1543 VSS.n121 VSS.t117 0.20525
R1544 VSS.n121 VSS.t127 0.20525
R1545 VSS.n119 VSS.t155 0.20525
R1546 VSS.n119 VSS.t141 0.20525
R1547 VSS.n117 VSS.t115 0.20525
R1548 VSS.n117 VSS.t123 0.20525
R1549 VSS.n115 VSS.t73 0.20525
R1550 VSS.n115 VSS.t95 0.20525
R1551 VSS.n113 VSS.t65 0.20525
R1552 VSS.n113 VSS.t83 0.20525
R1553 VSS.n111 VSS.t11 0.20525
R1554 VSS.n111 VSS.t27 0.20525
R1555 VSS.n109 VSS.t71 0.20525
R1556 VSS.n109 VSS.t41 0.20525
R1557 VSS.n108 VSS.t63 0.20525
R1558 VSS.n108 VSS.t109 0.20525
R1559 VSS.n105 VSS.t97 0.20525
R1560 VSS.n105 VSS.t287 0.20525
R1561 VSS.n103 VSS.t143 0.20525
R1562 VSS.n103 VSS.t99 0.20525
R1563 VSS.n101 VSS.t87 0.20525
R1564 VSS.n101 VSS.t145 0.20525
R1565 VSS.n100 VSS.t35 0.20525
R1566 VSS.n100 VSS.t89 0.20525
R1567 VSS.n168 VSS.t37 0.20525
R1568 VSS.n168 VSS.t91 0.20525
R1569 VSS.n166 VSS.t15 0.20525
R1570 VSS.n166 VSS.t153 0.20525
R1571 VSS.n164 VSS.t43 0.20525
R1572 VSS.n164 VSS.t17 0.20525
R1573 VSS.n163 VSS.t101 0.20525
R1574 VSS.n163 VSS.t45 0.20525
R1575 VSS.n160 VSS.t213 0.20525
R1576 VSS.n160 VSS.t215 0.20525
R1577 VSS.n158 VSS.t193 0.20525
R1578 VSS.n158 VSS.t211 0.20525
R1579 VSS.n156 VSS.t197 0.20525
R1580 VSS.n156 VSS.t177 0.20525
R1581 VSS.n154 VSS.t207 0.20525
R1582 VSS.n154 VSS.t209 0.20525
R1583 VSS.n152 VSS.t203 0.20525
R1584 VSS.n152 VSS.t205 0.20525
R1585 VSS.n150 VSS.t179 0.20525
R1586 VSS.n150 VSS.t201 0.20525
R1587 VSS.n148 VSS.t181 0.20525
R1588 VSS.n148 VSS.t187 0.20525
R1589 VSS.n147 VSS.t199 0.20525
R1590 VSS.n147 VSS.t195 0.20525
R1591 VSS.n144 VSS.t189 0.20525
R1592 VSS.n144 VSS.t191 0.20525
R1593 VSS.n143 VSS.t183 0.20525
R1594 VSS.n143 VSS.t185 0.20525
R1595 VSS.n95 VSS.t217 0.20525
R1596 VSS.n95 VSS.t223 0.20525
R1597 VSS.n94 VSS.t221 0.20525
R1598 VSS.n94 VSS.t219 0.20525
R1599 VSS.n21 VSS.n19 0.189974
R1600 VSS.n23 VSS.n21 0.189974
R1601 VSS.n25 VSS.n23 0.189974
R1602 VSS.n27 VSS.n25 0.189974
R1603 VSS.n29 VSS.n27 0.189974
R1604 VSS.n31 VSS.n29 0.189974
R1605 VSS.n33 VSS.n31 0.189974
R1606 VSS.n35 VSS.n33 0.189974
R1607 VSS.n37 VSS.n35 0.189974
R1608 VSS.n39 VSS.n37 0.189974
R1609 VSS.n41 VSS.n39 0.189974
R1610 VSS.n43 VSS.n41 0.189974
R1611 VSS.n45 VSS.n43 0.189974
R1612 VSS.n47 VSS.n45 0.189974
R1613 VSS.n13 VSS.n11 0.189974
R1614 VSS.n15 VSS.n13 0.189974
R1615 VSS.n57 VSS.n55 0.189974
R1616 VSS.n59 VSS.n57 0.189974
R1617 VSS.n65 VSS.n63 0.189974
R1618 VSS.n67 VSS.n65 0.189974
R1619 VSS.n69 VSS.n67 0.189974
R1620 VSS.n71 VSS.n69 0.189974
R1621 VSS.n73 VSS.n71 0.189974
R1622 VSS.n75 VSS.n73 0.189974
R1623 VSS.n112 VSS.n110 0.189974
R1624 VSS.n114 VSS.n112 0.189974
R1625 VSS.n116 VSS.n114 0.189974
R1626 VSS.n118 VSS.n116 0.189974
R1627 VSS.n120 VSS.n118 0.189974
R1628 VSS.n122 VSS.n120 0.189974
R1629 VSS.n124 VSS.n122 0.189974
R1630 VSS.n126 VSS.n124 0.189974
R1631 VSS.n128 VSS.n126 0.189974
R1632 VSS.n130 VSS.n128 0.189974
R1633 VSS.n132 VSS.n130 0.189974
R1634 VSS.n134 VSS.n132 0.189974
R1635 VSS.n136 VSS.n134 0.189974
R1636 VSS.n138 VSS.n136 0.189974
R1637 VSS.n104 VSS.n102 0.189974
R1638 VSS.n106 VSS.n104 0.189974
R1639 VSS.n167 VSS.n165 0.189974
R1640 VSS.n169 VSS.n167 0.189974
R1641 VSS.n151 VSS.n149 0.189974
R1642 VSS.n153 VSS.n151 0.189974
R1643 VSS.n155 VSS.n153 0.189974
R1644 VSS.n157 VSS.n155 0.189974
R1645 VSS.n159 VSS.n157 0.189974
R1646 VSS.n161 VSS.n159 0.189974
R1647 VSS.n182 VSS.n0 0.020105
R1648 VSS.n60 VSS.n52 0.018725
R1649 VSS.n171 VSS.n170 0.018725
R1650 VSS.n87 VSS.n5 0.00725
R1651 VSS.n85 VSS.n5 0.00725
R1652 VSS.n52 VSS.n51 0.00725
R1653 VSS.n51 VSS.n7 0.00725
R1654 VSS.n175 VSS.n93 0.00725
R1655 VSS.n175 VSS.n174 0.00725
R1656 VSS.n171 VSS.n142 0.00725
R1657 VSS.n142 VSS.n99 0.00725
R1658 VSS.n181 VSS.n180 0.0054955
R1659 VSS.n181 VSS.n1 0.0054955
R1660 VSS.n8 VSS.n6 0.0045
R1661 VSS.n172 VSS.n98 0.0045
R1662 a_6924_6400.n90 a_6924_6400.t63 113.632
R1663 a_6924_6400.n112 a_6924_6400.t32 113.632
R1664 a_6924_6400.n29 a_6924_6400.t95 113.632
R1665 a_6924_6400.n51 a_6924_6400.t64 113.632
R1666 a_6924_6400.n133 a_6924_6400.t47 109.174
R1667 a_6924_6400.n134 a_6924_6400.t48 109.174
R1668 a_6924_6400.n91 a_6924_6400.t62 109.174
R1669 a_6924_6400.n92 a_6924_6400.t61 109.174
R1670 a_6924_6400.n93 a_6924_6400.t60 109.174
R1671 a_6924_6400.n94 a_6924_6400.t59 109.174
R1672 a_6924_6400.n95 a_6924_6400.t58 109.174
R1673 a_6924_6400.n96 a_6924_6400.t57 109.174
R1674 a_6924_6400.n97 a_6924_6400.t56 109.174
R1675 a_6924_6400.n98 a_6924_6400.t55 109.174
R1676 a_6924_6400.n99 a_6924_6400.t54 109.174
R1677 a_6924_6400.n100 a_6924_6400.t53 109.174
R1678 a_6924_6400.n101 a_6924_6400.t52 109.174
R1679 a_6924_6400.n102 a_6924_6400.t51 109.174
R1680 a_6924_6400.n103 a_6924_6400.t50 109.174
R1681 a_6924_6400.n104 a_6924_6400.t49 109.174
R1682 a_6924_6400.n132 a_6924_6400.t46 109.174
R1683 a_6924_6400.n105 a_6924_6400.t45 109.174
R1684 a_6924_6400.n128 a_6924_6400.t44 109.174
R1685 a_6924_6400.n127 a_6924_6400.t43 109.174
R1686 a_6924_6400.n126 a_6924_6400.t42 109.174
R1687 a_6924_6400.n107 a_6924_6400.t41 109.174
R1688 a_6924_6400.n122 a_6924_6400.t40 109.174
R1689 a_6924_6400.n121 a_6924_6400.t39 109.174
R1690 a_6924_6400.n120 a_6924_6400.t38 109.174
R1691 a_6924_6400.n109 a_6924_6400.t37 109.174
R1692 a_6924_6400.n116 a_6924_6400.t36 109.174
R1693 a_6924_6400.n115 a_6924_6400.t35 109.174
R1694 a_6924_6400.n114 a_6924_6400.t34 109.174
R1695 a_6924_6400.n111 a_6924_6400.t33 109.174
R1696 a_6924_6400.n72 a_6924_6400.t79 109.174
R1697 a_6924_6400.n73 a_6924_6400.t80 109.174
R1698 a_6924_6400.n30 a_6924_6400.t94 109.174
R1699 a_6924_6400.n31 a_6924_6400.t93 109.174
R1700 a_6924_6400.n32 a_6924_6400.t92 109.174
R1701 a_6924_6400.n33 a_6924_6400.t91 109.174
R1702 a_6924_6400.n34 a_6924_6400.t90 109.174
R1703 a_6924_6400.n35 a_6924_6400.t89 109.174
R1704 a_6924_6400.n36 a_6924_6400.t88 109.174
R1705 a_6924_6400.n37 a_6924_6400.t87 109.174
R1706 a_6924_6400.n38 a_6924_6400.t86 109.174
R1707 a_6924_6400.n39 a_6924_6400.t85 109.174
R1708 a_6924_6400.n40 a_6924_6400.t84 109.174
R1709 a_6924_6400.n41 a_6924_6400.t83 109.174
R1710 a_6924_6400.n42 a_6924_6400.t82 109.174
R1711 a_6924_6400.n43 a_6924_6400.t81 109.174
R1712 a_6924_6400.n71 a_6924_6400.t78 109.174
R1713 a_6924_6400.n44 a_6924_6400.t77 109.174
R1714 a_6924_6400.n67 a_6924_6400.t76 109.174
R1715 a_6924_6400.n66 a_6924_6400.t75 109.174
R1716 a_6924_6400.n65 a_6924_6400.t74 109.174
R1717 a_6924_6400.n46 a_6924_6400.t73 109.174
R1718 a_6924_6400.n61 a_6924_6400.t72 109.174
R1719 a_6924_6400.n60 a_6924_6400.t71 109.174
R1720 a_6924_6400.n59 a_6924_6400.t70 109.174
R1721 a_6924_6400.n48 a_6924_6400.t69 109.174
R1722 a_6924_6400.n55 a_6924_6400.t68 109.174
R1723 a_6924_6400.n54 a_6924_6400.t67 109.174
R1724 a_6924_6400.n53 a_6924_6400.t66 109.174
R1725 a_6924_6400.n50 a_6924_6400.t65 109.174
R1726 a_6924_6400.n138 a_6924_6400.n137 22.4584
R1727 a_6924_6400.n133 a_6924_6400.n76 18.4942
R1728 a_6924_6400.n135 a_6924_6400.n134 18.4942
R1729 a_6924_6400.n92 a_6924_6400.n89 18.4942
R1730 a_6924_6400.n93 a_6924_6400.n88 18.4942
R1731 a_6924_6400.n94 a_6924_6400.n87 18.4942
R1732 a_6924_6400.n95 a_6924_6400.n86 18.4942
R1733 a_6924_6400.n96 a_6924_6400.n85 18.4942
R1734 a_6924_6400.n97 a_6924_6400.n84 18.4942
R1735 a_6924_6400.n98 a_6924_6400.n83 18.4942
R1736 a_6924_6400.n99 a_6924_6400.n82 18.4942
R1737 a_6924_6400.n100 a_6924_6400.n81 18.4942
R1738 a_6924_6400.n101 a_6924_6400.n80 18.4942
R1739 a_6924_6400.n102 a_6924_6400.n79 18.4942
R1740 a_6924_6400.n103 a_6924_6400.n78 18.4942
R1741 a_6924_6400.n104 a_6924_6400.n77 18.4942
R1742 a_6924_6400.n132 a_6924_6400.n131 18.4942
R1743 a_6924_6400.n130 a_6924_6400.n105 18.4942
R1744 a_6924_6400.n129 a_6924_6400.n128 18.4942
R1745 a_6924_6400.n127 a_6924_6400.n106 18.4942
R1746 a_6924_6400.n126 a_6924_6400.n125 18.4942
R1747 a_6924_6400.n124 a_6924_6400.n107 18.4942
R1748 a_6924_6400.n123 a_6924_6400.n122 18.4942
R1749 a_6924_6400.n121 a_6924_6400.n108 18.4942
R1750 a_6924_6400.n120 a_6924_6400.n119 18.4942
R1751 a_6924_6400.n118 a_6924_6400.n109 18.4942
R1752 a_6924_6400.n117 a_6924_6400.n116 18.4942
R1753 a_6924_6400.n115 a_6924_6400.n110 18.4942
R1754 a_6924_6400.n114 a_6924_6400.n113 18.4942
R1755 a_6924_6400.n72 a_6924_6400.n15 18.4942
R1756 a_6924_6400.n74 a_6924_6400.n73 18.4942
R1757 a_6924_6400.n31 a_6924_6400.n28 18.4942
R1758 a_6924_6400.n32 a_6924_6400.n27 18.4942
R1759 a_6924_6400.n33 a_6924_6400.n26 18.4942
R1760 a_6924_6400.n34 a_6924_6400.n25 18.4942
R1761 a_6924_6400.n35 a_6924_6400.n24 18.4942
R1762 a_6924_6400.n36 a_6924_6400.n23 18.4942
R1763 a_6924_6400.n37 a_6924_6400.n22 18.4942
R1764 a_6924_6400.n38 a_6924_6400.n21 18.4942
R1765 a_6924_6400.n39 a_6924_6400.n20 18.4942
R1766 a_6924_6400.n40 a_6924_6400.n19 18.4942
R1767 a_6924_6400.n41 a_6924_6400.n18 18.4942
R1768 a_6924_6400.n42 a_6924_6400.n17 18.4942
R1769 a_6924_6400.n43 a_6924_6400.n16 18.4942
R1770 a_6924_6400.n71 a_6924_6400.n70 18.4942
R1771 a_6924_6400.n69 a_6924_6400.n44 18.4942
R1772 a_6924_6400.n68 a_6924_6400.n67 18.4942
R1773 a_6924_6400.n66 a_6924_6400.n45 18.4942
R1774 a_6924_6400.n65 a_6924_6400.n64 18.4942
R1775 a_6924_6400.n63 a_6924_6400.n46 18.4942
R1776 a_6924_6400.n62 a_6924_6400.n61 18.4942
R1777 a_6924_6400.n60 a_6924_6400.n47 18.4942
R1778 a_6924_6400.n59 a_6924_6400.n58 18.4942
R1779 a_6924_6400.n57 a_6924_6400.n48 18.4942
R1780 a_6924_6400.n56 a_6924_6400.n55 18.4942
R1781 a_6924_6400.n54 a_6924_6400.n49 18.4942
R1782 a_6924_6400.n53 a_6924_6400.n52 18.4942
R1783 a_6924_6400.n133 a_6924_6400.n132 11.6805
R1784 a_6924_6400.n134 a_6924_6400.n133 11.6805
R1785 a_6924_6400.n92 a_6924_6400.n91 11.6805
R1786 a_6924_6400.n93 a_6924_6400.n92 11.6805
R1787 a_6924_6400.n94 a_6924_6400.n93 11.6805
R1788 a_6924_6400.n95 a_6924_6400.n94 11.6805
R1789 a_6924_6400.n96 a_6924_6400.n95 11.6805
R1790 a_6924_6400.n97 a_6924_6400.n96 11.6805
R1791 a_6924_6400.n98 a_6924_6400.n97 11.6805
R1792 a_6924_6400.n99 a_6924_6400.n98 11.6805
R1793 a_6924_6400.n100 a_6924_6400.n99 11.6805
R1794 a_6924_6400.n101 a_6924_6400.n100 11.6805
R1795 a_6924_6400.n102 a_6924_6400.n101 11.6805
R1796 a_6924_6400.n103 a_6924_6400.n102 11.6805
R1797 a_6924_6400.n104 a_6924_6400.n103 11.6805
R1798 a_6924_6400.n134 a_6924_6400.n104 11.6805
R1799 a_6924_6400.n132 a_6924_6400.n105 11.6805
R1800 a_6924_6400.n128 a_6924_6400.n105 11.6805
R1801 a_6924_6400.n128 a_6924_6400.n127 11.6805
R1802 a_6924_6400.n127 a_6924_6400.n126 11.6805
R1803 a_6924_6400.n126 a_6924_6400.n107 11.6805
R1804 a_6924_6400.n122 a_6924_6400.n107 11.6805
R1805 a_6924_6400.n122 a_6924_6400.n121 11.6805
R1806 a_6924_6400.n121 a_6924_6400.n120 11.6805
R1807 a_6924_6400.n120 a_6924_6400.n109 11.6805
R1808 a_6924_6400.n116 a_6924_6400.n109 11.6805
R1809 a_6924_6400.n116 a_6924_6400.n115 11.6805
R1810 a_6924_6400.n115 a_6924_6400.n114 11.6805
R1811 a_6924_6400.n114 a_6924_6400.n111 11.6805
R1812 a_6924_6400.n72 a_6924_6400.n71 11.6805
R1813 a_6924_6400.n73 a_6924_6400.n72 11.6805
R1814 a_6924_6400.n31 a_6924_6400.n30 11.6805
R1815 a_6924_6400.n32 a_6924_6400.n31 11.6805
R1816 a_6924_6400.n33 a_6924_6400.n32 11.6805
R1817 a_6924_6400.n34 a_6924_6400.n33 11.6805
R1818 a_6924_6400.n35 a_6924_6400.n34 11.6805
R1819 a_6924_6400.n36 a_6924_6400.n35 11.6805
R1820 a_6924_6400.n37 a_6924_6400.n36 11.6805
R1821 a_6924_6400.n38 a_6924_6400.n37 11.6805
R1822 a_6924_6400.n39 a_6924_6400.n38 11.6805
R1823 a_6924_6400.n40 a_6924_6400.n39 11.6805
R1824 a_6924_6400.n41 a_6924_6400.n40 11.6805
R1825 a_6924_6400.n42 a_6924_6400.n41 11.6805
R1826 a_6924_6400.n43 a_6924_6400.n42 11.6805
R1827 a_6924_6400.n73 a_6924_6400.n43 11.6805
R1828 a_6924_6400.n71 a_6924_6400.n44 11.6805
R1829 a_6924_6400.n67 a_6924_6400.n44 11.6805
R1830 a_6924_6400.n67 a_6924_6400.n66 11.6805
R1831 a_6924_6400.n66 a_6924_6400.n65 11.6805
R1832 a_6924_6400.n65 a_6924_6400.n46 11.6805
R1833 a_6924_6400.n61 a_6924_6400.n46 11.6805
R1834 a_6924_6400.n61 a_6924_6400.n60 11.6805
R1835 a_6924_6400.n60 a_6924_6400.n59 11.6805
R1836 a_6924_6400.n59 a_6924_6400.n48 11.6805
R1837 a_6924_6400.n55 a_6924_6400.n48 11.6805
R1838 a_6924_6400.n55 a_6924_6400.n54 11.6805
R1839 a_6924_6400.n54 a_6924_6400.n53 11.6805
R1840 a_6924_6400.n53 a_6924_6400.n50 11.6805
R1841 a_6924_6400.n137 a_6924_6400.n75 10.9291
R1842 a_6924_6400.n137 a_6924_6400.n136 9.0005
R1843 a_6924_6400.n113 a_6924_6400.n112 7.17687
R1844 a_6924_6400.n90 a_6924_6400.n89 7.17687
R1845 a_6924_6400.n52 a_6924_6400.n51 7.17687
R1846 a_6924_6400.n29 a_6924_6400.n28 7.17687
R1847 a_6924_6400.n138 a_6924_6400.n14 6.5392
R1848 a_6924_6400.t15 a_6924_6400.n153 5.7796
R1849 a_6924_6400.n1 a_6924_6400.t31 5.73764
R1850 a_6924_6400.n139 a_6924_6400.t0 5.59012
R1851 a_6924_6400.n14 a_6924_6400.t16 5.54817
R1852 a_6924_6400.n153 a_6924_6400.n152 5.38537
R1853 a_6924_6400.n151 a_6924_6400.n150 5.38537
R1854 a_6924_6400.n149 a_6924_6400.n148 5.38537
R1855 a_6924_6400.n147 a_6924_6400.n146 5.38537
R1856 a_6924_6400.n145 a_6924_6400.n144 5.38537
R1857 a_6924_6400.n143 a_6924_6400.n142 5.38537
R1858 a_6924_6400.n141 a_6924_6400.n140 5.38537
R1859 a_6924_6400.n1 a_6924_6400.n0 5.32067
R1860 a_6924_6400.n3 a_6924_6400.n2 5.32067
R1861 a_6924_6400.n5 a_6924_6400.n4 5.32067
R1862 a_6924_6400.n7 a_6924_6400.n6 5.32067
R1863 a_6924_6400.n9 a_6924_6400.n8 5.32067
R1864 a_6924_6400.n11 a_6924_6400.n10 5.32067
R1865 a_6924_6400.n13 a_6924_6400.n12 5.32067
R1866 a_6924_6400.n139 a_6924_6400.n138 4.61063
R1867 a_6924_6400.n91 a_6924_6400.n90 4.42851
R1868 a_6924_6400.n112 a_6924_6400.n111 4.42851
R1869 a_6924_6400.n30 a_6924_6400.n29 4.42851
R1870 a_6924_6400.n51 a_6924_6400.n50 4.42851
R1871 a_6924_6400.n0 a_6924_6400.t29 0.228
R1872 a_6924_6400.n0 a_6924_6400.t30 0.228
R1873 a_6924_6400.n2 a_6924_6400.t27 0.228
R1874 a_6924_6400.n2 a_6924_6400.t28 0.228
R1875 a_6924_6400.n4 a_6924_6400.t25 0.228
R1876 a_6924_6400.n4 a_6924_6400.t26 0.228
R1877 a_6924_6400.n6 a_6924_6400.t23 0.228
R1878 a_6924_6400.n6 a_6924_6400.t24 0.228
R1879 a_6924_6400.n8 a_6924_6400.t21 0.228
R1880 a_6924_6400.n8 a_6924_6400.t22 0.228
R1881 a_6924_6400.n10 a_6924_6400.t19 0.228
R1882 a_6924_6400.n10 a_6924_6400.t20 0.228
R1883 a_6924_6400.n12 a_6924_6400.t17 0.228
R1884 a_6924_6400.n12 a_6924_6400.t18 0.228
R1885 a_6924_6400.n152 a_6924_6400.t13 0.20525
R1886 a_6924_6400.n152 a_6924_6400.t14 0.20525
R1887 a_6924_6400.n150 a_6924_6400.t11 0.20525
R1888 a_6924_6400.n150 a_6924_6400.t12 0.20525
R1889 a_6924_6400.n148 a_6924_6400.t9 0.20525
R1890 a_6924_6400.n148 a_6924_6400.t10 0.20525
R1891 a_6924_6400.n146 a_6924_6400.t7 0.20525
R1892 a_6924_6400.n146 a_6924_6400.t8 0.20525
R1893 a_6924_6400.n144 a_6924_6400.t5 0.20525
R1894 a_6924_6400.n144 a_6924_6400.t6 0.20525
R1895 a_6924_6400.n142 a_6924_6400.t3 0.20525
R1896 a_6924_6400.n142 a_6924_6400.t4 0.20525
R1897 a_6924_6400.n140 a_6924_6400.t1 0.20525
R1898 a_6924_6400.n140 a_6924_6400.t2 0.20525
R1899 a_6924_6400.n141 a_6924_6400.n139 0.189974
R1900 a_6924_6400.n143 a_6924_6400.n141 0.189974
R1901 a_6924_6400.n145 a_6924_6400.n143 0.189974
R1902 a_6924_6400.n147 a_6924_6400.n145 0.189974
R1903 a_6924_6400.n149 a_6924_6400.n147 0.189974
R1904 a_6924_6400.n151 a_6924_6400.n149 0.189974
R1905 a_6924_6400.n153 a_6924_6400.n151 0.189974
R1906 a_6924_6400.n14 a_6924_6400.n13 0.189974
R1907 a_6924_6400.n13 a_6924_6400.n11 0.189974
R1908 a_6924_6400.n11 a_6924_6400.n9 0.189974
R1909 a_6924_6400.n9 a_6924_6400.n7 0.189974
R1910 a_6924_6400.n7 a_6924_6400.n5 0.189974
R1911 a_6924_6400.n5 a_6924_6400.n3 0.189974
R1912 a_6924_6400.n3 a_6924_6400.n1 0.189974
R1913 a_6924_6400.n131 a_6924_6400.n76 0.1205
R1914 a_6924_6400.n131 a_6924_6400.n130 0.1205
R1915 a_6924_6400.n130 a_6924_6400.n129 0.1205
R1916 a_6924_6400.n129 a_6924_6400.n106 0.1205
R1917 a_6924_6400.n125 a_6924_6400.n106 0.1205
R1918 a_6924_6400.n125 a_6924_6400.n124 0.1205
R1919 a_6924_6400.n124 a_6924_6400.n123 0.1205
R1920 a_6924_6400.n123 a_6924_6400.n108 0.1205
R1921 a_6924_6400.n119 a_6924_6400.n108 0.1205
R1922 a_6924_6400.n119 a_6924_6400.n118 0.1205
R1923 a_6924_6400.n118 a_6924_6400.n117 0.1205
R1924 a_6924_6400.n117 a_6924_6400.n110 0.1205
R1925 a_6924_6400.n113 a_6924_6400.n110 0.1205
R1926 a_6924_6400.n89 a_6924_6400.n88 0.1205
R1927 a_6924_6400.n88 a_6924_6400.n87 0.1205
R1928 a_6924_6400.n87 a_6924_6400.n86 0.1205
R1929 a_6924_6400.n86 a_6924_6400.n85 0.1205
R1930 a_6924_6400.n85 a_6924_6400.n84 0.1205
R1931 a_6924_6400.n84 a_6924_6400.n83 0.1205
R1932 a_6924_6400.n83 a_6924_6400.n82 0.1205
R1933 a_6924_6400.n82 a_6924_6400.n81 0.1205
R1934 a_6924_6400.n81 a_6924_6400.n80 0.1205
R1935 a_6924_6400.n80 a_6924_6400.n79 0.1205
R1936 a_6924_6400.n79 a_6924_6400.n78 0.1205
R1937 a_6924_6400.n78 a_6924_6400.n77 0.1205
R1938 a_6924_6400.n135 a_6924_6400.n77 0.1205
R1939 a_6924_6400.n70 a_6924_6400.n15 0.1205
R1940 a_6924_6400.n70 a_6924_6400.n69 0.1205
R1941 a_6924_6400.n69 a_6924_6400.n68 0.1205
R1942 a_6924_6400.n68 a_6924_6400.n45 0.1205
R1943 a_6924_6400.n64 a_6924_6400.n45 0.1205
R1944 a_6924_6400.n64 a_6924_6400.n63 0.1205
R1945 a_6924_6400.n63 a_6924_6400.n62 0.1205
R1946 a_6924_6400.n62 a_6924_6400.n47 0.1205
R1947 a_6924_6400.n58 a_6924_6400.n47 0.1205
R1948 a_6924_6400.n58 a_6924_6400.n57 0.1205
R1949 a_6924_6400.n57 a_6924_6400.n56 0.1205
R1950 a_6924_6400.n56 a_6924_6400.n49 0.1205
R1951 a_6924_6400.n52 a_6924_6400.n49 0.1205
R1952 a_6924_6400.n28 a_6924_6400.n27 0.1205
R1953 a_6924_6400.n27 a_6924_6400.n26 0.1205
R1954 a_6924_6400.n26 a_6924_6400.n25 0.1205
R1955 a_6924_6400.n25 a_6924_6400.n24 0.1205
R1956 a_6924_6400.n24 a_6924_6400.n23 0.1205
R1957 a_6924_6400.n23 a_6924_6400.n22 0.1205
R1958 a_6924_6400.n22 a_6924_6400.n21 0.1205
R1959 a_6924_6400.n21 a_6924_6400.n20 0.1205
R1960 a_6924_6400.n20 a_6924_6400.n19 0.1205
R1961 a_6924_6400.n19 a_6924_6400.n18 0.1205
R1962 a_6924_6400.n18 a_6924_6400.n17 0.1205
R1963 a_6924_6400.n17 a_6924_6400.n16 0.1205
R1964 a_6924_6400.n74 a_6924_6400.n16 0.1205
R1965 a_6924_6400.n136 a_6924_6400.n76 0.0485
R1966 a_6924_6400.n136 a_6924_6400.n135 0.0485
R1967 a_6924_6400.n75 a_6924_6400.n15 0.0485
R1968 a_6924_6400.n75 a_6924_6400.n74 0.0485
R1969 a_4812_6400.n18 a_4812_6400.t15 113.632
R1970 a_4812_6400.n22 a_4812_6400.t8 113.632
R1971 a_4812_6400.n5 a_4812_6400.t23 113.632
R1972 a_4812_6400.n9 a_4812_6400.t16 113.632
R1973 a_4812_6400.n25 a_4812_6400.t11 109.174
R1974 a_4812_6400.n26 a_4812_6400.t12 109.174
R1975 a_4812_6400.n19 a_4812_6400.t14 109.174
R1976 a_4812_6400.n20 a_4812_6400.t13 109.174
R1977 a_4812_6400.n24 a_4812_6400.t10 109.174
R1978 a_4812_6400.n21 a_4812_6400.t9 109.174
R1979 a_4812_6400.n12 a_4812_6400.t19 109.174
R1980 a_4812_6400.n13 a_4812_6400.t20 109.174
R1981 a_4812_6400.n6 a_4812_6400.t22 109.174
R1982 a_4812_6400.n7 a_4812_6400.t21 109.174
R1983 a_4812_6400.n11 a_4812_6400.t18 109.174
R1984 a_4812_6400.n8 a_4812_6400.t17 109.174
R1985 a_4812_6400.n30 a_4812_6400.n29 19.1827
R1986 a_4812_6400.n25 a_4812_6400.n16 18.4942
R1987 a_4812_6400.n27 a_4812_6400.n26 18.4942
R1988 a_4812_6400.n20 a_4812_6400.n17 18.4942
R1989 a_4812_6400.n24 a_4812_6400.n23 18.4942
R1990 a_4812_6400.n12 a_4812_6400.n3 18.4942
R1991 a_4812_6400.n14 a_4812_6400.n13 18.4942
R1992 a_4812_6400.n7 a_4812_6400.n4 18.4942
R1993 a_4812_6400.n11 a_4812_6400.n10 18.4942
R1994 a_4812_6400.n25 a_4812_6400.n24 11.6805
R1995 a_4812_6400.n26 a_4812_6400.n25 11.6805
R1996 a_4812_6400.n20 a_4812_6400.n19 11.6805
R1997 a_4812_6400.n26 a_4812_6400.n20 11.6805
R1998 a_4812_6400.n24 a_4812_6400.n21 11.6805
R1999 a_4812_6400.n12 a_4812_6400.n11 11.6805
R2000 a_4812_6400.n13 a_4812_6400.n12 11.6805
R2001 a_4812_6400.n7 a_4812_6400.n6 11.6805
R2002 a_4812_6400.n13 a_4812_6400.n7 11.6805
R2003 a_4812_6400.n11 a_4812_6400.n8 11.6805
R2004 a_4812_6400.n29 a_4812_6400.n15 10.3505
R2005 a_4812_6400.n29 a_4812_6400.n28 9.57907
R2006 a_4812_6400.n23 a_4812_6400.n22 7.17687
R2007 a_4812_6400.n18 a_4812_6400.n17 7.17687
R2008 a_4812_6400.n10 a_4812_6400.n9 7.17687
R2009 a_4812_6400.n5 a_4812_6400.n4 7.17687
R2010 a_4812_6400.n30 a_4812_6400.n2 6.5392
R2011 a_4812_6400.t3 a_4812_6400.n33 5.7796
R2012 a_4812_6400.n1 a_4812_6400.t7 5.73764
R2013 a_4812_6400.n31 a_4812_6400.t0 5.59012
R2014 a_4812_6400.n2 a_4812_6400.t4 5.54817
R2015 a_4812_6400.n33 a_4812_6400.n32 5.38537
R2016 a_4812_6400.n1 a_4812_6400.n0 5.32067
R2017 a_4812_6400.n31 a_4812_6400.n30 4.61063
R2018 a_4812_6400.n19 a_4812_6400.n18 4.42851
R2019 a_4812_6400.n22 a_4812_6400.n21 4.42851
R2020 a_4812_6400.n6 a_4812_6400.n5 4.42851
R2021 a_4812_6400.n9 a_4812_6400.n8 4.42851
R2022 a_4812_6400.n0 a_4812_6400.t5 0.228
R2023 a_4812_6400.n0 a_4812_6400.t6 0.228
R2024 a_4812_6400.n32 a_4812_6400.t1 0.20525
R2025 a_4812_6400.n32 a_4812_6400.t2 0.20525
R2026 a_4812_6400.n33 a_4812_6400.n31 0.189974
R2027 a_4812_6400.n2 a_4812_6400.n1 0.189974
R2028 a_4812_6400.n23 a_4812_6400.n16 0.1205
R2029 a_4812_6400.n27 a_4812_6400.n17 0.1205
R2030 a_4812_6400.n10 a_4812_6400.n3 0.1205
R2031 a_4812_6400.n14 a_4812_6400.n4 0.1205
R2032 a_4812_6400.n28 a_4812_6400.n16 0.0485
R2033 a_4812_6400.n28 a_4812_6400.n27 0.0485
R2034 a_4812_6400.n15 a_4812_6400.n3 0.0485
R2035 a_4812_6400.n15 a_4812_6400.n14 0.0485
R2036 a_2700_6400.n18 a_2700_6400.t15 113.632
R2037 a_2700_6400.n22 a_2700_6400.t8 113.632
R2038 a_2700_6400.n5 a_2700_6400.t23 113.632
R2039 a_2700_6400.n9 a_2700_6400.t16 113.632
R2040 a_2700_6400.n25 a_2700_6400.t11 109.174
R2041 a_2700_6400.n26 a_2700_6400.t12 109.174
R2042 a_2700_6400.n19 a_2700_6400.t14 109.174
R2043 a_2700_6400.n20 a_2700_6400.t13 109.174
R2044 a_2700_6400.n24 a_2700_6400.t10 109.174
R2045 a_2700_6400.n21 a_2700_6400.t9 109.174
R2046 a_2700_6400.n12 a_2700_6400.t19 109.174
R2047 a_2700_6400.n13 a_2700_6400.t20 109.174
R2048 a_2700_6400.n6 a_2700_6400.t22 109.174
R2049 a_2700_6400.n7 a_2700_6400.t21 109.174
R2050 a_2700_6400.n11 a_2700_6400.t18 109.174
R2051 a_2700_6400.n8 a_2700_6400.t17 109.174
R2052 a_2700_6400.n30 a_2700_6400.n29 18.8941
R2053 a_2700_6400.n25 a_2700_6400.n16 18.4942
R2054 a_2700_6400.n27 a_2700_6400.n26 18.4942
R2055 a_2700_6400.n20 a_2700_6400.n17 18.4942
R2056 a_2700_6400.n24 a_2700_6400.n23 18.4942
R2057 a_2700_6400.n12 a_2700_6400.n3 18.4942
R2058 a_2700_6400.n14 a_2700_6400.n13 18.4942
R2059 a_2700_6400.n7 a_2700_6400.n4 18.4942
R2060 a_2700_6400.n11 a_2700_6400.n10 18.4942
R2061 a_2700_6400.n25 a_2700_6400.n24 11.6805
R2062 a_2700_6400.n26 a_2700_6400.n25 11.6805
R2063 a_2700_6400.n20 a_2700_6400.n19 11.6805
R2064 a_2700_6400.n26 a_2700_6400.n20 11.6805
R2065 a_2700_6400.n24 a_2700_6400.n21 11.6805
R2066 a_2700_6400.n12 a_2700_6400.n11 11.6805
R2067 a_2700_6400.n13 a_2700_6400.n12 11.6805
R2068 a_2700_6400.n7 a_2700_6400.n6 11.6805
R2069 a_2700_6400.n13 a_2700_6400.n7 11.6805
R2070 a_2700_6400.n11 a_2700_6400.n8 11.6805
R2071 a_2700_6400.n29 a_2700_6400.n15 10.688
R2072 a_2700_6400.n29 a_2700_6400.n28 9.24157
R2073 a_2700_6400.n23 a_2700_6400.n22 7.17687
R2074 a_2700_6400.n18 a_2700_6400.n17 7.17687
R2075 a_2700_6400.n10 a_2700_6400.n9 7.17687
R2076 a_2700_6400.n5 a_2700_6400.n4 7.17687
R2077 a_2700_6400.n30 a_2700_6400.n2 6.5392
R2078 a_2700_6400.t3 a_2700_6400.n33 5.7796
R2079 a_2700_6400.n1 a_2700_6400.t7 5.73764
R2080 a_2700_6400.n31 a_2700_6400.t0 5.59012
R2081 a_2700_6400.n2 a_2700_6400.t4 5.54817
R2082 a_2700_6400.n33 a_2700_6400.n32 5.38537
R2083 a_2700_6400.n1 a_2700_6400.n0 5.32067
R2084 a_2700_6400.n31 a_2700_6400.n30 4.61063
R2085 a_2700_6400.n19 a_2700_6400.n18 4.42851
R2086 a_2700_6400.n22 a_2700_6400.n21 4.42851
R2087 a_2700_6400.n6 a_2700_6400.n5 4.42851
R2088 a_2700_6400.n9 a_2700_6400.n8 4.42851
R2089 a_2700_6400.n0 a_2700_6400.t5 0.228
R2090 a_2700_6400.n0 a_2700_6400.t6 0.228
R2091 a_2700_6400.n32 a_2700_6400.t1 0.20525
R2092 a_2700_6400.n32 a_2700_6400.t2 0.20525
R2093 a_2700_6400.n33 a_2700_6400.n31 0.189974
R2094 a_2700_6400.n2 a_2700_6400.n1 0.189974
R2095 a_2700_6400.n23 a_2700_6400.n16 0.1205
R2096 a_2700_6400.n27 a_2700_6400.n17 0.1205
R2097 a_2700_6400.n10 a_2700_6400.n3 0.1205
R2098 a_2700_6400.n14 a_2700_6400.n4 0.1205
R2099 a_2700_6400.n28 a_2700_6400.n16 0.0485
R2100 a_2700_6400.n28 a_2700_6400.n27 0.0485
R2101 a_2700_6400.n15 a_2700_6400.n3 0.0485
R2102 a_2700_6400.n15 a_2700_6400.n14 0.0485
R2103 a_6924_41600.n90 a_6924_41600.t63 113.632
R2104 a_6924_41600.n112 a_6924_41600.t32 113.632
R2105 a_6924_41600.n29 a_6924_41600.t95 113.632
R2106 a_6924_41600.n51 a_6924_41600.t64 113.632
R2107 a_6924_41600.n133 a_6924_41600.t47 109.174
R2108 a_6924_41600.n134 a_6924_41600.t48 109.174
R2109 a_6924_41600.n91 a_6924_41600.t62 109.174
R2110 a_6924_41600.n92 a_6924_41600.t61 109.174
R2111 a_6924_41600.n93 a_6924_41600.t60 109.174
R2112 a_6924_41600.n94 a_6924_41600.t59 109.174
R2113 a_6924_41600.n95 a_6924_41600.t58 109.174
R2114 a_6924_41600.n96 a_6924_41600.t57 109.174
R2115 a_6924_41600.n97 a_6924_41600.t56 109.174
R2116 a_6924_41600.n98 a_6924_41600.t55 109.174
R2117 a_6924_41600.n99 a_6924_41600.t54 109.174
R2118 a_6924_41600.n100 a_6924_41600.t53 109.174
R2119 a_6924_41600.n101 a_6924_41600.t52 109.174
R2120 a_6924_41600.n102 a_6924_41600.t51 109.174
R2121 a_6924_41600.n103 a_6924_41600.t50 109.174
R2122 a_6924_41600.n104 a_6924_41600.t49 109.174
R2123 a_6924_41600.n132 a_6924_41600.t46 109.174
R2124 a_6924_41600.n105 a_6924_41600.t45 109.174
R2125 a_6924_41600.n128 a_6924_41600.t44 109.174
R2126 a_6924_41600.n127 a_6924_41600.t43 109.174
R2127 a_6924_41600.n126 a_6924_41600.t42 109.174
R2128 a_6924_41600.n107 a_6924_41600.t41 109.174
R2129 a_6924_41600.n122 a_6924_41600.t40 109.174
R2130 a_6924_41600.n121 a_6924_41600.t39 109.174
R2131 a_6924_41600.n120 a_6924_41600.t38 109.174
R2132 a_6924_41600.n109 a_6924_41600.t37 109.174
R2133 a_6924_41600.n116 a_6924_41600.t36 109.174
R2134 a_6924_41600.n115 a_6924_41600.t35 109.174
R2135 a_6924_41600.n114 a_6924_41600.t34 109.174
R2136 a_6924_41600.n111 a_6924_41600.t33 109.174
R2137 a_6924_41600.n72 a_6924_41600.t79 109.174
R2138 a_6924_41600.n73 a_6924_41600.t80 109.174
R2139 a_6924_41600.n30 a_6924_41600.t94 109.174
R2140 a_6924_41600.n31 a_6924_41600.t93 109.174
R2141 a_6924_41600.n32 a_6924_41600.t92 109.174
R2142 a_6924_41600.n33 a_6924_41600.t91 109.174
R2143 a_6924_41600.n34 a_6924_41600.t90 109.174
R2144 a_6924_41600.n35 a_6924_41600.t89 109.174
R2145 a_6924_41600.n36 a_6924_41600.t88 109.174
R2146 a_6924_41600.n37 a_6924_41600.t87 109.174
R2147 a_6924_41600.n38 a_6924_41600.t86 109.174
R2148 a_6924_41600.n39 a_6924_41600.t85 109.174
R2149 a_6924_41600.n40 a_6924_41600.t84 109.174
R2150 a_6924_41600.n41 a_6924_41600.t83 109.174
R2151 a_6924_41600.n42 a_6924_41600.t82 109.174
R2152 a_6924_41600.n43 a_6924_41600.t81 109.174
R2153 a_6924_41600.n71 a_6924_41600.t78 109.174
R2154 a_6924_41600.n44 a_6924_41600.t77 109.174
R2155 a_6924_41600.n67 a_6924_41600.t76 109.174
R2156 a_6924_41600.n66 a_6924_41600.t75 109.174
R2157 a_6924_41600.n65 a_6924_41600.t74 109.174
R2158 a_6924_41600.n46 a_6924_41600.t73 109.174
R2159 a_6924_41600.n61 a_6924_41600.t72 109.174
R2160 a_6924_41600.n60 a_6924_41600.t71 109.174
R2161 a_6924_41600.n59 a_6924_41600.t70 109.174
R2162 a_6924_41600.n48 a_6924_41600.t69 109.174
R2163 a_6924_41600.n55 a_6924_41600.t68 109.174
R2164 a_6924_41600.n54 a_6924_41600.t67 109.174
R2165 a_6924_41600.n53 a_6924_41600.t66 109.174
R2166 a_6924_41600.n50 a_6924_41600.t65 109.174
R2167 a_6924_41600.n138 a_6924_41600.n137 22.4584
R2168 a_6924_41600.n133 a_6924_41600.n76 18.4942
R2169 a_6924_41600.n135 a_6924_41600.n134 18.4942
R2170 a_6924_41600.n92 a_6924_41600.n89 18.4942
R2171 a_6924_41600.n93 a_6924_41600.n88 18.4942
R2172 a_6924_41600.n94 a_6924_41600.n87 18.4942
R2173 a_6924_41600.n95 a_6924_41600.n86 18.4942
R2174 a_6924_41600.n96 a_6924_41600.n85 18.4942
R2175 a_6924_41600.n97 a_6924_41600.n84 18.4942
R2176 a_6924_41600.n98 a_6924_41600.n83 18.4942
R2177 a_6924_41600.n99 a_6924_41600.n82 18.4942
R2178 a_6924_41600.n100 a_6924_41600.n81 18.4942
R2179 a_6924_41600.n101 a_6924_41600.n80 18.4942
R2180 a_6924_41600.n102 a_6924_41600.n79 18.4942
R2181 a_6924_41600.n103 a_6924_41600.n78 18.4942
R2182 a_6924_41600.n104 a_6924_41600.n77 18.4942
R2183 a_6924_41600.n132 a_6924_41600.n131 18.4942
R2184 a_6924_41600.n130 a_6924_41600.n105 18.4942
R2185 a_6924_41600.n129 a_6924_41600.n128 18.4942
R2186 a_6924_41600.n127 a_6924_41600.n106 18.4942
R2187 a_6924_41600.n126 a_6924_41600.n125 18.4942
R2188 a_6924_41600.n124 a_6924_41600.n107 18.4942
R2189 a_6924_41600.n123 a_6924_41600.n122 18.4942
R2190 a_6924_41600.n121 a_6924_41600.n108 18.4942
R2191 a_6924_41600.n120 a_6924_41600.n119 18.4942
R2192 a_6924_41600.n118 a_6924_41600.n109 18.4942
R2193 a_6924_41600.n117 a_6924_41600.n116 18.4942
R2194 a_6924_41600.n115 a_6924_41600.n110 18.4942
R2195 a_6924_41600.n114 a_6924_41600.n113 18.4942
R2196 a_6924_41600.n72 a_6924_41600.n15 18.4942
R2197 a_6924_41600.n74 a_6924_41600.n73 18.4942
R2198 a_6924_41600.n31 a_6924_41600.n28 18.4942
R2199 a_6924_41600.n32 a_6924_41600.n27 18.4942
R2200 a_6924_41600.n33 a_6924_41600.n26 18.4942
R2201 a_6924_41600.n34 a_6924_41600.n25 18.4942
R2202 a_6924_41600.n35 a_6924_41600.n24 18.4942
R2203 a_6924_41600.n36 a_6924_41600.n23 18.4942
R2204 a_6924_41600.n37 a_6924_41600.n22 18.4942
R2205 a_6924_41600.n38 a_6924_41600.n21 18.4942
R2206 a_6924_41600.n39 a_6924_41600.n20 18.4942
R2207 a_6924_41600.n40 a_6924_41600.n19 18.4942
R2208 a_6924_41600.n41 a_6924_41600.n18 18.4942
R2209 a_6924_41600.n42 a_6924_41600.n17 18.4942
R2210 a_6924_41600.n43 a_6924_41600.n16 18.4942
R2211 a_6924_41600.n71 a_6924_41600.n70 18.4942
R2212 a_6924_41600.n69 a_6924_41600.n44 18.4942
R2213 a_6924_41600.n68 a_6924_41600.n67 18.4942
R2214 a_6924_41600.n66 a_6924_41600.n45 18.4942
R2215 a_6924_41600.n65 a_6924_41600.n64 18.4942
R2216 a_6924_41600.n63 a_6924_41600.n46 18.4942
R2217 a_6924_41600.n62 a_6924_41600.n61 18.4942
R2218 a_6924_41600.n60 a_6924_41600.n47 18.4942
R2219 a_6924_41600.n59 a_6924_41600.n58 18.4942
R2220 a_6924_41600.n57 a_6924_41600.n48 18.4942
R2221 a_6924_41600.n56 a_6924_41600.n55 18.4942
R2222 a_6924_41600.n54 a_6924_41600.n49 18.4942
R2223 a_6924_41600.n53 a_6924_41600.n52 18.4942
R2224 a_6924_41600.n133 a_6924_41600.n132 11.6805
R2225 a_6924_41600.n134 a_6924_41600.n133 11.6805
R2226 a_6924_41600.n92 a_6924_41600.n91 11.6805
R2227 a_6924_41600.n93 a_6924_41600.n92 11.6805
R2228 a_6924_41600.n94 a_6924_41600.n93 11.6805
R2229 a_6924_41600.n95 a_6924_41600.n94 11.6805
R2230 a_6924_41600.n96 a_6924_41600.n95 11.6805
R2231 a_6924_41600.n97 a_6924_41600.n96 11.6805
R2232 a_6924_41600.n98 a_6924_41600.n97 11.6805
R2233 a_6924_41600.n99 a_6924_41600.n98 11.6805
R2234 a_6924_41600.n100 a_6924_41600.n99 11.6805
R2235 a_6924_41600.n101 a_6924_41600.n100 11.6805
R2236 a_6924_41600.n102 a_6924_41600.n101 11.6805
R2237 a_6924_41600.n103 a_6924_41600.n102 11.6805
R2238 a_6924_41600.n104 a_6924_41600.n103 11.6805
R2239 a_6924_41600.n134 a_6924_41600.n104 11.6805
R2240 a_6924_41600.n132 a_6924_41600.n105 11.6805
R2241 a_6924_41600.n128 a_6924_41600.n105 11.6805
R2242 a_6924_41600.n128 a_6924_41600.n127 11.6805
R2243 a_6924_41600.n127 a_6924_41600.n126 11.6805
R2244 a_6924_41600.n126 a_6924_41600.n107 11.6805
R2245 a_6924_41600.n122 a_6924_41600.n107 11.6805
R2246 a_6924_41600.n122 a_6924_41600.n121 11.6805
R2247 a_6924_41600.n121 a_6924_41600.n120 11.6805
R2248 a_6924_41600.n120 a_6924_41600.n109 11.6805
R2249 a_6924_41600.n116 a_6924_41600.n109 11.6805
R2250 a_6924_41600.n116 a_6924_41600.n115 11.6805
R2251 a_6924_41600.n115 a_6924_41600.n114 11.6805
R2252 a_6924_41600.n114 a_6924_41600.n111 11.6805
R2253 a_6924_41600.n72 a_6924_41600.n71 11.6805
R2254 a_6924_41600.n73 a_6924_41600.n72 11.6805
R2255 a_6924_41600.n31 a_6924_41600.n30 11.6805
R2256 a_6924_41600.n32 a_6924_41600.n31 11.6805
R2257 a_6924_41600.n33 a_6924_41600.n32 11.6805
R2258 a_6924_41600.n34 a_6924_41600.n33 11.6805
R2259 a_6924_41600.n35 a_6924_41600.n34 11.6805
R2260 a_6924_41600.n36 a_6924_41600.n35 11.6805
R2261 a_6924_41600.n37 a_6924_41600.n36 11.6805
R2262 a_6924_41600.n38 a_6924_41600.n37 11.6805
R2263 a_6924_41600.n39 a_6924_41600.n38 11.6805
R2264 a_6924_41600.n40 a_6924_41600.n39 11.6805
R2265 a_6924_41600.n41 a_6924_41600.n40 11.6805
R2266 a_6924_41600.n42 a_6924_41600.n41 11.6805
R2267 a_6924_41600.n43 a_6924_41600.n42 11.6805
R2268 a_6924_41600.n73 a_6924_41600.n43 11.6805
R2269 a_6924_41600.n71 a_6924_41600.n44 11.6805
R2270 a_6924_41600.n67 a_6924_41600.n44 11.6805
R2271 a_6924_41600.n67 a_6924_41600.n66 11.6805
R2272 a_6924_41600.n66 a_6924_41600.n65 11.6805
R2273 a_6924_41600.n65 a_6924_41600.n46 11.6805
R2274 a_6924_41600.n61 a_6924_41600.n46 11.6805
R2275 a_6924_41600.n61 a_6924_41600.n60 11.6805
R2276 a_6924_41600.n60 a_6924_41600.n59 11.6805
R2277 a_6924_41600.n59 a_6924_41600.n48 11.6805
R2278 a_6924_41600.n55 a_6924_41600.n48 11.6805
R2279 a_6924_41600.n55 a_6924_41600.n54 11.6805
R2280 a_6924_41600.n54 a_6924_41600.n53 11.6805
R2281 a_6924_41600.n53 a_6924_41600.n50 11.6805
R2282 a_6924_41600.n137 a_6924_41600.n75 10.9291
R2283 a_6924_41600.n137 a_6924_41600.n136 9.0005
R2284 a_6924_41600.n113 a_6924_41600.n112 7.17687
R2285 a_6924_41600.n90 a_6924_41600.n89 7.17687
R2286 a_6924_41600.n52 a_6924_41600.n51 7.17687
R2287 a_6924_41600.n29 a_6924_41600.n28 7.17687
R2288 a_6924_41600.n138 a_6924_41600.n14 6.5392
R2289 a_6924_41600.t15 a_6924_41600.n153 5.7796
R2290 a_6924_41600.n1 a_6924_41600.t31 5.73764
R2291 a_6924_41600.n139 a_6924_41600.t0 5.59012
R2292 a_6924_41600.n14 a_6924_41600.t16 5.54817
R2293 a_6924_41600.n153 a_6924_41600.n152 5.38537
R2294 a_6924_41600.n151 a_6924_41600.n150 5.38537
R2295 a_6924_41600.n149 a_6924_41600.n148 5.38537
R2296 a_6924_41600.n147 a_6924_41600.n146 5.38537
R2297 a_6924_41600.n145 a_6924_41600.n144 5.38537
R2298 a_6924_41600.n143 a_6924_41600.n142 5.38537
R2299 a_6924_41600.n141 a_6924_41600.n140 5.38537
R2300 a_6924_41600.n1 a_6924_41600.n0 5.32067
R2301 a_6924_41600.n3 a_6924_41600.n2 5.32067
R2302 a_6924_41600.n5 a_6924_41600.n4 5.32067
R2303 a_6924_41600.n7 a_6924_41600.n6 5.32067
R2304 a_6924_41600.n9 a_6924_41600.n8 5.32067
R2305 a_6924_41600.n11 a_6924_41600.n10 5.32067
R2306 a_6924_41600.n13 a_6924_41600.n12 5.32067
R2307 a_6924_41600.n139 a_6924_41600.n138 4.61063
R2308 a_6924_41600.n91 a_6924_41600.n90 4.42851
R2309 a_6924_41600.n112 a_6924_41600.n111 4.42851
R2310 a_6924_41600.n30 a_6924_41600.n29 4.42851
R2311 a_6924_41600.n51 a_6924_41600.n50 4.42851
R2312 a_6924_41600.n0 a_6924_41600.t29 0.228
R2313 a_6924_41600.n0 a_6924_41600.t30 0.228
R2314 a_6924_41600.n2 a_6924_41600.t27 0.228
R2315 a_6924_41600.n2 a_6924_41600.t28 0.228
R2316 a_6924_41600.n4 a_6924_41600.t25 0.228
R2317 a_6924_41600.n4 a_6924_41600.t26 0.228
R2318 a_6924_41600.n6 a_6924_41600.t23 0.228
R2319 a_6924_41600.n6 a_6924_41600.t24 0.228
R2320 a_6924_41600.n8 a_6924_41600.t21 0.228
R2321 a_6924_41600.n8 a_6924_41600.t22 0.228
R2322 a_6924_41600.n10 a_6924_41600.t19 0.228
R2323 a_6924_41600.n10 a_6924_41600.t20 0.228
R2324 a_6924_41600.n12 a_6924_41600.t17 0.228
R2325 a_6924_41600.n12 a_6924_41600.t18 0.228
R2326 a_6924_41600.n152 a_6924_41600.t13 0.20525
R2327 a_6924_41600.n152 a_6924_41600.t14 0.20525
R2328 a_6924_41600.n150 a_6924_41600.t11 0.20525
R2329 a_6924_41600.n150 a_6924_41600.t12 0.20525
R2330 a_6924_41600.n148 a_6924_41600.t9 0.20525
R2331 a_6924_41600.n148 a_6924_41600.t10 0.20525
R2332 a_6924_41600.n146 a_6924_41600.t7 0.20525
R2333 a_6924_41600.n146 a_6924_41600.t8 0.20525
R2334 a_6924_41600.n144 a_6924_41600.t5 0.20525
R2335 a_6924_41600.n144 a_6924_41600.t6 0.20525
R2336 a_6924_41600.n142 a_6924_41600.t3 0.20525
R2337 a_6924_41600.n142 a_6924_41600.t4 0.20525
R2338 a_6924_41600.n140 a_6924_41600.t1 0.20525
R2339 a_6924_41600.n140 a_6924_41600.t2 0.20525
R2340 a_6924_41600.n141 a_6924_41600.n139 0.189974
R2341 a_6924_41600.n143 a_6924_41600.n141 0.189974
R2342 a_6924_41600.n145 a_6924_41600.n143 0.189974
R2343 a_6924_41600.n147 a_6924_41600.n145 0.189974
R2344 a_6924_41600.n149 a_6924_41600.n147 0.189974
R2345 a_6924_41600.n151 a_6924_41600.n149 0.189974
R2346 a_6924_41600.n153 a_6924_41600.n151 0.189974
R2347 a_6924_41600.n14 a_6924_41600.n13 0.189974
R2348 a_6924_41600.n13 a_6924_41600.n11 0.189974
R2349 a_6924_41600.n11 a_6924_41600.n9 0.189974
R2350 a_6924_41600.n9 a_6924_41600.n7 0.189974
R2351 a_6924_41600.n7 a_6924_41600.n5 0.189974
R2352 a_6924_41600.n5 a_6924_41600.n3 0.189974
R2353 a_6924_41600.n3 a_6924_41600.n1 0.189974
R2354 a_6924_41600.n131 a_6924_41600.n76 0.1205
R2355 a_6924_41600.n131 a_6924_41600.n130 0.1205
R2356 a_6924_41600.n130 a_6924_41600.n129 0.1205
R2357 a_6924_41600.n129 a_6924_41600.n106 0.1205
R2358 a_6924_41600.n125 a_6924_41600.n106 0.1205
R2359 a_6924_41600.n125 a_6924_41600.n124 0.1205
R2360 a_6924_41600.n124 a_6924_41600.n123 0.1205
R2361 a_6924_41600.n123 a_6924_41600.n108 0.1205
R2362 a_6924_41600.n119 a_6924_41600.n108 0.1205
R2363 a_6924_41600.n119 a_6924_41600.n118 0.1205
R2364 a_6924_41600.n118 a_6924_41600.n117 0.1205
R2365 a_6924_41600.n117 a_6924_41600.n110 0.1205
R2366 a_6924_41600.n113 a_6924_41600.n110 0.1205
R2367 a_6924_41600.n89 a_6924_41600.n88 0.1205
R2368 a_6924_41600.n88 a_6924_41600.n87 0.1205
R2369 a_6924_41600.n87 a_6924_41600.n86 0.1205
R2370 a_6924_41600.n86 a_6924_41600.n85 0.1205
R2371 a_6924_41600.n85 a_6924_41600.n84 0.1205
R2372 a_6924_41600.n84 a_6924_41600.n83 0.1205
R2373 a_6924_41600.n83 a_6924_41600.n82 0.1205
R2374 a_6924_41600.n82 a_6924_41600.n81 0.1205
R2375 a_6924_41600.n81 a_6924_41600.n80 0.1205
R2376 a_6924_41600.n80 a_6924_41600.n79 0.1205
R2377 a_6924_41600.n79 a_6924_41600.n78 0.1205
R2378 a_6924_41600.n78 a_6924_41600.n77 0.1205
R2379 a_6924_41600.n135 a_6924_41600.n77 0.1205
R2380 a_6924_41600.n70 a_6924_41600.n15 0.1205
R2381 a_6924_41600.n70 a_6924_41600.n69 0.1205
R2382 a_6924_41600.n69 a_6924_41600.n68 0.1205
R2383 a_6924_41600.n68 a_6924_41600.n45 0.1205
R2384 a_6924_41600.n64 a_6924_41600.n45 0.1205
R2385 a_6924_41600.n64 a_6924_41600.n63 0.1205
R2386 a_6924_41600.n63 a_6924_41600.n62 0.1205
R2387 a_6924_41600.n62 a_6924_41600.n47 0.1205
R2388 a_6924_41600.n58 a_6924_41600.n47 0.1205
R2389 a_6924_41600.n58 a_6924_41600.n57 0.1205
R2390 a_6924_41600.n57 a_6924_41600.n56 0.1205
R2391 a_6924_41600.n56 a_6924_41600.n49 0.1205
R2392 a_6924_41600.n52 a_6924_41600.n49 0.1205
R2393 a_6924_41600.n28 a_6924_41600.n27 0.1205
R2394 a_6924_41600.n27 a_6924_41600.n26 0.1205
R2395 a_6924_41600.n26 a_6924_41600.n25 0.1205
R2396 a_6924_41600.n25 a_6924_41600.n24 0.1205
R2397 a_6924_41600.n24 a_6924_41600.n23 0.1205
R2398 a_6924_41600.n23 a_6924_41600.n22 0.1205
R2399 a_6924_41600.n22 a_6924_41600.n21 0.1205
R2400 a_6924_41600.n21 a_6924_41600.n20 0.1205
R2401 a_6924_41600.n20 a_6924_41600.n19 0.1205
R2402 a_6924_41600.n19 a_6924_41600.n18 0.1205
R2403 a_6924_41600.n18 a_6924_41600.n17 0.1205
R2404 a_6924_41600.n17 a_6924_41600.n16 0.1205
R2405 a_6924_41600.n74 a_6924_41600.n16 0.1205
R2406 a_6924_41600.n136 a_6924_41600.n76 0.0485
R2407 a_6924_41600.n136 a_6924_41600.n135 0.0485
R2408 a_6924_41600.n75 a_6924_41600.n15 0.0485
R2409 a_6924_41600.n75 a_6924_41600.n74 0.0485
R2410 a_4812_41600.n18 a_4812_41600.t15 113.632
R2411 a_4812_41600.n22 a_4812_41600.t8 113.632
R2412 a_4812_41600.n5 a_4812_41600.t23 113.632
R2413 a_4812_41600.n9 a_4812_41600.t16 113.632
R2414 a_4812_41600.n25 a_4812_41600.t11 109.174
R2415 a_4812_41600.n26 a_4812_41600.t12 109.174
R2416 a_4812_41600.n19 a_4812_41600.t14 109.174
R2417 a_4812_41600.n20 a_4812_41600.t13 109.174
R2418 a_4812_41600.n24 a_4812_41600.t10 109.174
R2419 a_4812_41600.n21 a_4812_41600.t9 109.174
R2420 a_4812_41600.n12 a_4812_41600.t19 109.174
R2421 a_4812_41600.n13 a_4812_41600.t20 109.174
R2422 a_4812_41600.n6 a_4812_41600.t22 109.174
R2423 a_4812_41600.n7 a_4812_41600.t21 109.174
R2424 a_4812_41600.n11 a_4812_41600.t18 109.174
R2425 a_4812_41600.n8 a_4812_41600.t17 109.174
R2426 a_4812_41600.n30 a_4812_41600.n29 19.1827
R2427 a_4812_41600.n25 a_4812_41600.n16 18.4942
R2428 a_4812_41600.n27 a_4812_41600.n26 18.4942
R2429 a_4812_41600.n20 a_4812_41600.n17 18.4942
R2430 a_4812_41600.n24 a_4812_41600.n23 18.4942
R2431 a_4812_41600.n12 a_4812_41600.n3 18.4942
R2432 a_4812_41600.n14 a_4812_41600.n13 18.4942
R2433 a_4812_41600.n7 a_4812_41600.n4 18.4942
R2434 a_4812_41600.n11 a_4812_41600.n10 18.4942
R2435 a_4812_41600.n25 a_4812_41600.n24 11.6805
R2436 a_4812_41600.n26 a_4812_41600.n25 11.6805
R2437 a_4812_41600.n20 a_4812_41600.n19 11.6805
R2438 a_4812_41600.n26 a_4812_41600.n20 11.6805
R2439 a_4812_41600.n24 a_4812_41600.n21 11.6805
R2440 a_4812_41600.n12 a_4812_41600.n11 11.6805
R2441 a_4812_41600.n13 a_4812_41600.n12 11.6805
R2442 a_4812_41600.n7 a_4812_41600.n6 11.6805
R2443 a_4812_41600.n13 a_4812_41600.n7 11.6805
R2444 a_4812_41600.n11 a_4812_41600.n8 11.6805
R2445 a_4812_41600.n29 a_4812_41600.n15 10.3505
R2446 a_4812_41600.n29 a_4812_41600.n28 9.57907
R2447 a_4812_41600.n23 a_4812_41600.n22 7.17687
R2448 a_4812_41600.n18 a_4812_41600.n17 7.17687
R2449 a_4812_41600.n10 a_4812_41600.n9 7.17687
R2450 a_4812_41600.n5 a_4812_41600.n4 7.17687
R2451 a_4812_41600.n30 a_4812_41600.n2 6.5392
R2452 a_4812_41600.t3 a_4812_41600.n33 5.7796
R2453 a_4812_41600.n1 a_4812_41600.t7 5.73764
R2454 a_4812_41600.n31 a_4812_41600.t0 5.59012
R2455 a_4812_41600.n2 a_4812_41600.t4 5.54817
R2456 a_4812_41600.n33 a_4812_41600.n32 5.38537
R2457 a_4812_41600.n1 a_4812_41600.n0 5.32067
R2458 a_4812_41600.n31 a_4812_41600.n30 4.61063
R2459 a_4812_41600.n19 a_4812_41600.n18 4.42851
R2460 a_4812_41600.n22 a_4812_41600.n21 4.42851
R2461 a_4812_41600.n6 a_4812_41600.n5 4.42851
R2462 a_4812_41600.n9 a_4812_41600.n8 4.42851
R2463 a_4812_41600.n0 a_4812_41600.t5 0.228
R2464 a_4812_41600.n0 a_4812_41600.t6 0.228
R2465 a_4812_41600.n32 a_4812_41600.t1 0.20525
R2466 a_4812_41600.n32 a_4812_41600.t2 0.20525
R2467 a_4812_41600.n33 a_4812_41600.n31 0.189974
R2468 a_4812_41600.n2 a_4812_41600.n1 0.189974
R2469 a_4812_41600.n23 a_4812_41600.n16 0.1205
R2470 a_4812_41600.n27 a_4812_41600.n17 0.1205
R2471 a_4812_41600.n10 a_4812_41600.n3 0.1205
R2472 a_4812_41600.n14 a_4812_41600.n4 0.1205
R2473 a_4812_41600.n28 a_4812_41600.n16 0.0485
R2474 a_4812_41600.n28 a_4812_41600.n27 0.0485
R2475 a_4812_41600.n15 a_4812_41600.n3 0.0485
R2476 a_4812_41600.n15 a_4812_41600.n14 0.0485
R2477 a_2700_41600.n18 a_2700_41600.t15 113.632
R2478 a_2700_41600.n22 a_2700_41600.t8 113.632
R2479 a_2700_41600.n5 a_2700_41600.t23 113.632
R2480 a_2700_41600.n9 a_2700_41600.t16 113.632
R2481 a_2700_41600.n25 a_2700_41600.t11 109.174
R2482 a_2700_41600.n26 a_2700_41600.t12 109.174
R2483 a_2700_41600.n19 a_2700_41600.t14 109.174
R2484 a_2700_41600.n20 a_2700_41600.t13 109.174
R2485 a_2700_41600.n24 a_2700_41600.t10 109.174
R2486 a_2700_41600.n21 a_2700_41600.t9 109.174
R2487 a_2700_41600.n12 a_2700_41600.t19 109.174
R2488 a_2700_41600.n13 a_2700_41600.t20 109.174
R2489 a_2700_41600.n6 a_2700_41600.t22 109.174
R2490 a_2700_41600.n7 a_2700_41600.t21 109.174
R2491 a_2700_41600.n11 a_2700_41600.t18 109.174
R2492 a_2700_41600.n8 a_2700_41600.t17 109.174
R2493 a_2700_41600.n30 a_2700_41600.n29 18.8941
R2494 a_2700_41600.n25 a_2700_41600.n16 18.4942
R2495 a_2700_41600.n27 a_2700_41600.n26 18.4942
R2496 a_2700_41600.n20 a_2700_41600.n17 18.4942
R2497 a_2700_41600.n24 a_2700_41600.n23 18.4942
R2498 a_2700_41600.n12 a_2700_41600.n3 18.4942
R2499 a_2700_41600.n14 a_2700_41600.n13 18.4942
R2500 a_2700_41600.n7 a_2700_41600.n4 18.4942
R2501 a_2700_41600.n11 a_2700_41600.n10 18.4942
R2502 a_2700_41600.n25 a_2700_41600.n24 11.6805
R2503 a_2700_41600.n26 a_2700_41600.n25 11.6805
R2504 a_2700_41600.n20 a_2700_41600.n19 11.6805
R2505 a_2700_41600.n26 a_2700_41600.n20 11.6805
R2506 a_2700_41600.n24 a_2700_41600.n21 11.6805
R2507 a_2700_41600.n12 a_2700_41600.n11 11.6805
R2508 a_2700_41600.n13 a_2700_41600.n12 11.6805
R2509 a_2700_41600.n7 a_2700_41600.n6 11.6805
R2510 a_2700_41600.n13 a_2700_41600.n7 11.6805
R2511 a_2700_41600.n11 a_2700_41600.n8 11.6805
R2512 a_2700_41600.n29 a_2700_41600.n15 10.688
R2513 a_2700_41600.n29 a_2700_41600.n28 9.24157
R2514 a_2700_41600.n23 a_2700_41600.n22 7.17687
R2515 a_2700_41600.n18 a_2700_41600.n17 7.17687
R2516 a_2700_41600.n10 a_2700_41600.n9 7.17687
R2517 a_2700_41600.n5 a_2700_41600.n4 7.17687
R2518 a_2700_41600.n30 a_2700_41600.n2 6.5392
R2519 a_2700_41600.t3 a_2700_41600.n33 5.7796
R2520 a_2700_41600.n1 a_2700_41600.t7 5.73764
R2521 a_2700_41600.n31 a_2700_41600.t0 5.59012
R2522 a_2700_41600.n2 a_2700_41600.t4 5.54817
R2523 a_2700_41600.n33 a_2700_41600.n32 5.38537
R2524 a_2700_41600.n1 a_2700_41600.n0 5.32067
R2525 a_2700_41600.n31 a_2700_41600.n30 4.61063
R2526 a_2700_41600.n19 a_2700_41600.n18 4.42851
R2527 a_2700_41600.n22 a_2700_41600.n21 4.42851
R2528 a_2700_41600.n6 a_2700_41600.n5 4.42851
R2529 a_2700_41600.n9 a_2700_41600.n8 4.42851
R2530 a_2700_41600.n0 a_2700_41600.t5 0.228
R2531 a_2700_41600.n0 a_2700_41600.t6 0.228
R2532 a_2700_41600.n32 a_2700_41600.t1 0.20525
R2533 a_2700_41600.n32 a_2700_41600.t2 0.20525
R2534 a_2700_41600.n33 a_2700_41600.n31 0.189974
R2535 a_2700_41600.n2 a_2700_41600.n1 0.189974
R2536 a_2700_41600.n23 a_2700_41600.n16 0.1205
R2537 a_2700_41600.n27 a_2700_41600.n17 0.1205
R2538 a_2700_41600.n10 a_2700_41600.n3 0.1205
R2539 a_2700_41600.n14 a_2700_41600.n4 0.1205
R2540 a_2700_41600.n28 a_2700_41600.n16 0.0485
R2541 a_2700_41600.n28 a_2700_41600.n27 0.0485
R2542 a_2700_41600.n15 a_2700_41600.n3 0.0485
R2543 a_2700_41600.n15 a_2700_41600.n14 0.0485
C0 VDD E_SENSE 41.1636f
C1 CLKN_H VDD 10.1343f
C2 VDD CLKP_H 10.1343f
C3 E_CAPTURE_CLKB E_CAPTURE_CLK 0.1173f
C4 VDD O_SENSE 41.1636f
C5 VDD O_CAPTURE_CLK 11.3069f
C6 O_CAPTURE_CLK O_SENSE 0.12955f
C7 CLKN_HB CLKN_H 0.01686f
C8 E_CAPTURE_CLK E_SENSE 0.12955f
C9 CLKN_HB VDD 1.54483f
C10 O_CAPTURE_CLKB VDD 11.3037f
C11 VDD E_CAPTURE_CLK 11.3069f
C12 VDD E_CAPTURE_CLKB 11.3037f
C13 O_CAPTURE_CLKB O_CAPTURE_CLK 0.1173f
C14 CLKP_H CLKP_HB 0.01686f
C15 VDD CLKP_HB 1.54483f
C16 E_SENSE VSS 42.58559f
C17 E_CAPTURE_CLK VSS 11.60053f
C18 E_CAPTURE_CLKB VSS 11.68386f
C19 CLKP_H VSS 21.90577f
C20 CLKP_HB VSS 5.56653f
C21 O_SENSE VSS 42.58559f
C22 O_CAPTURE_CLK VSS 11.60053f
C23 O_CAPTURE_CLKB VSS 11.68386f
C24 CLKN_H VSS 21.90577f
C25 CLKN_HB VSS 6.03473f
C26 VDD VSS 2.32822p
C27 a_2700_41600.t7 VSS 0.78854f
C28 a_2700_41600.t6 VSS 0.17544f
C29 a_2700_41600.t5 VSS 0.17544f
C30 a_2700_41600.n0 VSS 0.58882f
C31 a_2700_41600.n1 VSS 0.32366f
C32 a_2700_41600.t4 VSS 0.78325f
C33 a_2700_41600.n2 VSS 0.34956f
C34 a_2700_41600.n3 VSS 0.05443f
C35 a_2700_41600.n4 VSS 0.18804f
C36 a_2700_41600.n5 VSS 0.09294f
C37 a_2700_41600.n6 VSS 0.09963f
C38 a_2700_41600.n7 VSS 0.09963f
C39 a_2700_41600.n8 VSS 0.09963f
C40 a_2700_41600.n9 VSS 0.09294f
C41 a_2700_41600.n10 VSS 0.18804f
C42 a_2700_41600.n11 VSS 0.09963f
C43 a_2700_41600.n12 VSS 0.09963f
C44 a_2700_41600.n13 VSS 0.09963f
C45 a_2700_41600.n14 VSS 0.05443f
C46 a_2700_41600.n15 VSS 0.30557f
C47 a_2700_41600.n16 VSS 0.05443f
C48 a_2700_41600.n17 VSS 0.18804f
C49 a_2700_41600.n18 VSS 0.09294f
C50 a_2700_41600.n19 VSS 0.09963f
C51 a_2700_41600.n20 VSS 0.09963f
C52 a_2700_41600.n21 VSS 0.09963f
C53 a_2700_41600.n22 VSS 0.09294f
C54 a_2700_41600.n23 VSS 0.18804f
C55 a_2700_41600.n24 VSS 0.09963f
C56 a_2700_41600.n25 VSS 0.09963f
C57 a_2700_41600.n26 VSS 0.09963f
C58 a_2700_41600.n27 VSS 0.05443f
C59 a_2700_41600.n28 VSS 0.22887f
C60 a_2700_41600.n29 VSS 2.2996f
C61 a_2700_41600.n30 VSS 2.14321f
C62 a_2700_41600.t0 VSS 0.78184f
C63 a_2700_41600.n31 VSS 0.23703f
C64 a_2700_41600.t2 VSS 0.17544f
C65 a_2700_41600.t1 VSS 0.17544f
C66 a_2700_41600.n32 VSS 0.58448f
C67 a_2700_41600.n33 VSS 0.3294f
C68 a_2700_41600.t3 VSS 0.78713f
C69 a_4812_41600.t7 VSS 0.79416f
C70 a_4812_41600.t6 VSS 0.17991f
C71 a_4812_41600.t5 VSS 0.17991f
C72 a_4812_41600.n0 VSS 0.58985f
C73 a_4812_41600.n1 VSS 0.32422f
C74 a_4812_41600.t4 VSS 0.78887f
C75 a_4812_41600.n2 VSS 0.35018f
C76 a_4812_41600.n3 VSS 0.05453f
C77 a_4812_41600.n4 VSS 0.18837f
C78 a_4812_41600.n5 VSS 0.09311f
C79 a_4812_41600.n6 VSS 0.0998f
C80 a_4812_41600.n7 VSS 0.0998f
C81 a_4812_41600.n8 VSS 0.0998f
C82 a_4812_41600.n9 VSS 0.09311f
C83 a_4812_41600.n10 VSS 0.18837f
C84 a_4812_41600.n11 VSS 0.0998f
C85 a_4812_41600.n12 VSS 0.0998f
C86 a_4812_41600.n13 VSS 0.0998f
C87 a_4812_41600.n14 VSS 0.05453f
C88 a_4812_41600.n15 VSS 0.2832f
C89 a_4812_41600.n16 VSS 0.05453f
C90 a_4812_41600.n17 VSS 0.18837f
C91 a_4812_41600.n18 VSS 0.09311f
C92 a_4812_41600.n19 VSS 0.0998f
C93 a_4812_41600.n20 VSS 0.0998f
C94 a_4812_41600.n21 VSS 0.0998f
C95 a_4812_41600.n22 VSS 0.09311f
C96 a_4812_41600.n23 VSS 0.18837f
C97 a_4812_41600.n24 VSS 0.0998f
C98 a_4812_41600.n25 VSS 0.0998f
C99 a_4812_41600.n26 VSS 0.0998f
C100 a_4812_41600.n27 VSS 0.05453f
C101 a_4812_41600.n28 VSS 0.24182f
C102 a_4812_41600.n29 VSS 2.36975f
C103 a_4812_41600.n30 VSS 2.12363f
C104 a_4812_41600.t0 VSS 0.78745f
C105 a_4812_41600.n31 VSS 0.23744f
C106 a_4812_41600.t2 VSS 0.17991f
C107 a_4812_41600.t1 VSS 0.17991f
C108 a_4812_41600.n32 VSS 0.5855f
C109 a_4812_41600.n33 VSS 0.32998f
C110 a_4812_41600.t3 VSS 0.79275f
C111 a_6924_41600.t31 VSS 0.77549f
C112 a_6924_41600.t30 VSS 0.17698f
C113 a_6924_41600.t29 VSS 0.17698f
C114 a_6924_41600.n0 VSS 0.5747f
C115 a_6924_41600.n1 VSS 0.3159f
C116 a_6924_41600.t28 VSS 0.17698f
C117 a_6924_41600.t27 VSS 0.17698f
C118 a_6924_41600.n2 VSS 0.5747f
C119 a_6924_41600.n3 VSS 0.16491f
C120 a_6924_41600.t26 VSS 0.17698f
C121 a_6924_41600.t25 VSS 0.17698f
C122 a_6924_41600.n4 VSS 0.5747f
C123 a_6924_41600.n5 VSS 0.16491f
C124 a_6924_41600.t24 VSS 0.17698f
C125 a_6924_41600.t23 VSS 0.17698f
C126 a_6924_41600.n6 VSS 0.5747f
C127 a_6924_41600.n7 VSS 0.16491f
C128 a_6924_41600.t22 VSS 0.17698f
C129 a_6924_41600.t21 VSS 0.17698f
C130 a_6924_41600.n8 VSS 0.5747f
C131 a_6924_41600.n9 VSS 0.16491f
C132 a_6924_41600.t20 VSS 0.17698f
C133 a_6924_41600.t19 VSS 0.17698f
C134 a_6924_41600.n10 VSS 0.5747f
C135 a_6924_41600.n11 VSS 0.16491f
C136 a_6924_41600.t18 VSS 0.17698f
C137 a_6924_41600.t17 VSS 0.17698f
C138 a_6924_41600.n12 VSS 0.5747f
C139 a_6924_41600.n13 VSS 0.16491f
C140 a_6924_41600.t16 VSS 0.77033f
C141 a_6924_41600.n14 VSS 0.34118f
C142 a_6924_41600.n15 VSS 0.05313f
C143 a_6924_41600.n16 VSS 0.06306f
C144 a_6924_41600.n17 VSS 0.06306f
C145 a_6924_41600.n18 VSS 0.06306f
C146 a_6924_41600.n19 VSS 0.06306f
C147 a_6924_41600.n20 VSS 0.06306f
C148 a_6924_41600.n21 VSS 0.06306f
C149 a_6924_41600.n22 VSS 0.06306f
C150 a_6924_41600.n23 VSS 0.06306f
C151 a_6924_41600.n24 VSS 0.06306f
C152 a_6924_41600.n25 VSS 0.06306f
C153 a_6924_41600.n26 VSS 0.06306f
C154 a_6924_41600.n27 VSS 0.06306f
C155 a_6924_41600.n28 VSS 0.18353f
C156 a_6924_41600.n29 VSS 0.09071f
C157 a_6924_41600.n30 VSS 0.09724f
C158 a_6924_41600.n31 VSS 0.09724f
C159 a_6924_41600.n32 VSS 0.09724f
C160 a_6924_41600.n33 VSS 0.09724f
C161 a_6924_41600.n34 VSS 0.09724f
C162 a_6924_41600.n35 VSS 0.09724f
C163 a_6924_41600.n36 VSS 0.09724f
C164 a_6924_41600.n37 VSS 0.09724f
C165 a_6924_41600.n38 VSS 0.09724f
C166 a_6924_41600.n39 VSS 0.09724f
C167 a_6924_41600.n40 VSS 0.09724f
C168 a_6924_41600.n41 VSS 0.09724f
C169 a_6924_41600.n42 VSS 0.09724f
C170 a_6924_41600.n43 VSS 0.09724f
C171 a_6924_41600.n44 VSS 0.09724f
C172 a_6924_41600.n45 VSS 0.06306f
C173 a_6924_41600.n46 VSS 0.09724f
C174 a_6924_41600.n47 VSS 0.06306f
C175 a_6924_41600.n48 VSS 0.09724f
C176 a_6924_41600.n49 VSS 0.06306f
C177 a_6924_41600.n50 VSS 0.09724f
C178 a_6924_41600.n51 VSS 0.09071f
C179 a_6924_41600.n52 VSS 0.18353f
C180 a_6924_41600.n53 VSS 0.09724f
C181 a_6924_41600.n54 VSS 0.09724f
C182 a_6924_41600.n55 VSS 0.09724f
C183 a_6924_41600.n56 VSS 0.06306f
C184 a_6924_41600.n57 VSS 0.06306f
C185 a_6924_41600.n58 VSS 0.06306f
C186 a_6924_41600.n59 VSS 0.09724f
C187 a_6924_41600.n60 VSS 0.09724f
C188 a_6924_41600.n61 VSS 0.09724f
C189 a_6924_41600.n62 VSS 0.06306f
C190 a_6924_41600.n63 VSS 0.06306f
C191 a_6924_41600.n64 VSS 0.06306f
C192 a_6924_41600.n65 VSS 0.09724f
C193 a_6924_41600.n66 VSS 0.09724f
C194 a_6924_41600.n67 VSS 0.09724f
C195 a_6924_41600.n68 VSS 0.06306f
C196 a_6924_41600.n69 VSS 0.06306f
C197 a_6924_41600.n70 VSS 0.06306f
C198 a_6924_41600.n71 VSS 0.09724f
C199 a_6924_41600.n72 VSS 0.09724f
C200 a_6924_41600.n73 VSS 0.09724f
C201 a_6924_41600.n74 VSS 0.05313f
C202 a_6924_41600.n75 VSS 0.99092f
C203 a_6924_41600.n76 VSS 0.05313f
C204 a_6924_41600.n77 VSS 0.06306f
C205 a_6924_41600.n78 VSS 0.06306f
C206 a_6924_41600.n79 VSS 0.06306f
C207 a_6924_41600.n80 VSS 0.06306f
C208 a_6924_41600.n81 VSS 0.06306f
C209 a_6924_41600.n82 VSS 0.06306f
C210 a_6924_41600.n83 VSS 0.06306f
C211 a_6924_41600.n84 VSS 0.06306f
C212 a_6924_41600.n85 VSS 0.06306f
C213 a_6924_41600.n86 VSS 0.06306f
C214 a_6924_41600.n87 VSS 0.06306f
C215 a_6924_41600.n88 VSS 0.06306f
C216 a_6924_41600.n89 VSS 0.18353f
C217 a_6924_41600.n90 VSS 0.09071f
C218 a_6924_41600.n91 VSS 0.09724f
C219 a_6924_41600.n92 VSS 0.09724f
C220 a_6924_41600.n93 VSS 0.09724f
C221 a_6924_41600.n94 VSS 0.09724f
C222 a_6924_41600.n95 VSS 0.09724f
C223 a_6924_41600.n96 VSS 0.09724f
C224 a_6924_41600.n97 VSS 0.09724f
C225 a_6924_41600.n98 VSS 0.09724f
C226 a_6924_41600.n99 VSS 0.09724f
C227 a_6924_41600.n100 VSS 0.09724f
C228 a_6924_41600.n101 VSS 0.09724f
C229 a_6924_41600.n102 VSS 0.09724f
C230 a_6924_41600.n103 VSS 0.09724f
C231 a_6924_41600.n104 VSS 0.09724f
C232 a_6924_41600.n105 VSS 0.09724f
C233 a_6924_41600.n106 VSS 0.06306f
C234 a_6924_41600.n107 VSS 0.09724f
C235 a_6924_41600.n108 VSS 0.06306f
C236 a_6924_41600.n109 VSS 0.09724f
C237 a_6924_41600.n110 VSS 0.06306f
C238 a_6924_41600.n111 VSS 0.09724f
C239 a_6924_41600.n112 VSS 0.09071f
C240 a_6924_41600.n113 VSS 0.18353f
C241 a_6924_41600.n114 VSS 0.09724f
C242 a_6924_41600.n115 VSS 0.09724f
C243 a_6924_41600.n116 VSS 0.09724f
C244 a_6924_41600.n117 VSS 0.06306f
C245 a_6924_41600.n118 VSS 0.06306f
C246 a_6924_41600.n119 VSS 0.06306f
C247 a_6924_41600.n120 VSS 0.09724f
C248 a_6924_41600.n121 VSS 0.09724f
C249 a_6924_41600.n122 VSS 0.09724f
C250 a_6924_41600.n123 VSS 0.06306f
C251 a_6924_41600.n124 VSS 0.06306f
C252 a_6924_41600.n125 VSS 0.06306f
C253 a_6924_41600.n126 VSS 0.09724f
C254 a_6924_41600.n127 VSS 0.09724f
C255 a_6924_41600.n128 VSS 0.09724f
C256 a_6924_41600.n129 VSS 0.06306f
C257 a_6924_41600.n130 VSS 0.06306f
C258 a_6924_41600.n131 VSS 0.06306f
C259 a_6924_41600.n132 VSS 0.09724f
C260 a_6924_41600.n133 VSS 0.09724f
C261 a_6924_41600.n134 VSS 0.09724f
C262 a_6924_41600.n135 VSS 0.05313f
C263 a_6924_41600.n136 VSS 0.7909f
C264 a_6924_41600.n137 VSS 3.7383f
C265 a_6924_41600.n138 VSS 2.58064f
C266 a_6924_41600.t0 VSS 0.76895f
C267 a_6924_41600.n139 VSS 0.23134f
C268 a_6924_41600.t2 VSS 0.17698f
C269 a_6924_41600.t1 VSS 0.17698f
C270 a_6924_41600.n140 VSS 0.57047f
C271 a_6924_41600.n141 VSS 0.16914f
C272 a_6924_41600.t4 VSS 0.17698f
C273 a_6924_41600.t3 VSS 0.17698f
C274 a_6924_41600.n142 VSS 0.57047f
C275 a_6924_41600.n143 VSS 0.16914f
C276 a_6924_41600.t6 VSS 0.17698f
C277 a_6924_41600.t5 VSS 0.17698f
C278 a_6924_41600.n144 VSS 0.57047f
C279 a_6924_41600.n145 VSS 0.16914f
C280 a_6924_41600.t8 VSS 0.17698f
C281 a_6924_41600.t7 VSS 0.17698f
C282 a_6924_41600.n146 VSS 0.57047f
C283 a_6924_41600.n147 VSS 0.16914f
C284 a_6924_41600.t10 VSS 0.17698f
C285 a_6924_41600.t9 VSS 0.17698f
C286 a_6924_41600.n148 VSS 0.57047f
C287 a_6924_41600.n149 VSS 0.16914f
C288 a_6924_41600.t12 VSS 0.17698f
C289 a_6924_41600.t11 VSS 0.17698f
C290 a_6924_41600.n150 VSS 0.57047f
C291 a_6924_41600.n151 VSS 0.16914f
C292 a_6924_41600.t14 VSS 0.17698f
C293 a_6924_41600.t13 VSS 0.17698f
C294 a_6924_41600.n152 VSS 0.57047f
C295 a_6924_41600.n153 VSS 0.32151f
C296 a_6924_41600.t15 VSS 0.77412f
C297 a_2700_6400.t7 VSS 0.79099f
C298 a_2700_6400.t6 VSS 0.17785f
C299 a_2700_6400.t5 VSS 0.17785f
C300 a_2700_6400.n0 VSS 0.58882f
C301 a_2700_6400.n1 VSS 0.32366f
C302 a_2700_6400.t4 VSS 0.78571f
C303 a_2700_6400.n2 VSS 0.34956f
C304 a_2700_6400.n3 VSS 0.05443f
C305 a_2700_6400.n4 VSS 0.18804f
C306 a_2700_6400.n5 VSS 0.09294f
C307 a_2700_6400.n6 VSS 0.09963f
C308 a_2700_6400.n7 VSS 0.09963f
C309 a_2700_6400.n8 VSS 0.09963f
C310 a_2700_6400.n9 VSS 0.09294f
C311 a_2700_6400.n10 VSS 0.18804f
C312 a_2700_6400.n11 VSS 0.09963f
C313 a_2700_6400.n12 VSS 0.09963f
C314 a_2700_6400.n13 VSS 0.09963f
C315 a_2700_6400.n14 VSS 0.05443f
C316 a_2700_6400.n15 VSS 0.30557f
C317 a_2700_6400.n16 VSS 0.05443f
C318 a_2700_6400.n17 VSS 0.18804f
C319 a_2700_6400.n18 VSS 0.09294f
C320 a_2700_6400.n19 VSS 0.09963f
C321 a_2700_6400.n20 VSS 0.09963f
C322 a_2700_6400.n21 VSS 0.09963f
C323 a_2700_6400.n22 VSS 0.09294f
C324 a_2700_6400.n23 VSS 0.18804f
C325 a_2700_6400.n24 VSS 0.09963f
C326 a_2700_6400.n25 VSS 0.09963f
C327 a_2700_6400.n26 VSS 0.09963f
C328 a_2700_6400.n27 VSS 0.05443f
C329 a_2700_6400.n28 VSS 0.22887f
C330 a_2700_6400.n29 VSS 2.2996f
C331 a_2700_6400.n30 VSS 2.14321f
C332 a_2700_6400.t0 VSS 0.78429f
C333 a_2700_6400.n31 VSS 0.23703f
C334 a_2700_6400.t2 VSS 0.17785f
C335 a_2700_6400.t1 VSS 0.17785f
C336 a_2700_6400.n32 VSS 0.58448f
C337 a_2700_6400.n33 VSS 0.3294f
C338 a_2700_6400.t3 VSS 0.78958f
C339 a_4812_6400.t7 VSS 0.79416f
C340 a_4812_6400.t6 VSS 0.17991f
C341 a_4812_6400.t5 VSS 0.17991f
C342 a_4812_6400.n0 VSS 0.58985f
C343 a_4812_6400.n1 VSS 0.32422f
C344 a_4812_6400.t4 VSS 0.78887f
C345 a_4812_6400.n2 VSS 0.35018f
C346 a_4812_6400.n3 VSS 0.05453f
C347 a_4812_6400.n4 VSS 0.18837f
C348 a_4812_6400.n5 VSS 0.09311f
C349 a_4812_6400.n6 VSS 0.0998f
C350 a_4812_6400.n7 VSS 0.0998f
C351 a_4812_6400.n8 VSS 0.0998f
C352 a_4812_6400.n9 VSS 0.09311f
C353 a_4812_6400.n10 VSS 0.18837f
C354 a_4812_6400.n11 VSS 0.0998f
C355 a_4812_6400.n12 VSS 0.0998f
C356 a_4812_6400.n13 VSS 0.0998f
C357 a_4812_6400.n14 VSS 0.05453f
C358 a_4812_6400.n15 VSS 0.2832f
C359 a_4812_6400.n16 VSS 0.05453f
C360 a_4812_6400.n17 VSS 0.18837f
C361 a_4812_6400.n18 VSS 0.09311f
C362 a_4812_6400.n19 VSS 0.0998f
C363 a_4812_6400.n20 VSS 0.0998f
C364 a_4812_6400.n21 VSS 0.0998f
C365 a_4812_6400.n22 VSS 0.09311f
C366 a_4812_6400.n23 VSS 0.18837f
C367 a_4812_6400.n24 VSS 0.0998f
C368 a_4812_6400.n25 VSS 0.0998f
C369 a_4812_6400.n26 VSS 0.0998f
C370 a_4812_6400.n27 VSS 0.05453f
C371 a_4812_6400.n28 VSS 0.24182f
C372 a_4812_6400.n29 VSS 2.36975f
C373 a_4812_6400.n30 VSS 2.12363f
C374 a_4812_6400.t0 VSS 0.78745f
C375 a_4812_6400.n31 VSS 0.23744f
C376 a_4812_6400.t2 VSS 0.17991f
C377 a_4812_6400.t1 VSS 0.17991f
C378 a_4812_6400.n32 VSS 0.5855f
C379 a_4812_6400.n33 VSS 0.32998f
C380 a_4812_6400.t3 VSS 0.79275f
C381 a_6924_6400.t31 VSS 0.77549f
C382 a_6924_6400.t30 VSS 0.17698f
C383 a_6924_6400.t29 VSS 0.17698f
C384 a_6924_6400.n0 VSS 0.5747f
C385 a_6924_6400.n1 VSS 0.3159f
C386 a_6924_6400.t28 VSS 0.17698f
C387 a_6924_6400.t27 VSS 0.17698f
C388 a_6924_6400.n2 VSS 0.5747f
C389 a_6924_6400.n3 VSS 0.16491f
C390 a_6924_6400.t26 VSS 0.17698f
C391 a_6924_6400.t25 VSS 0.17698f
C392 a_6924_6400.n4 VSS 0.5747f
C393 a_6924_6400.n5 VSS 0.16491f
C394 a_6924_6400.t24 VSS 0.17698f
C395 a_6924_6400.t23 VSS 0.17698f
C396 a_6924_6400.n6 VSS 0.5747f
C397 a_6924_6400.n7 VSS 0.16491f
C398 a_6924_6400.t22 VSS 0.17698f
C399 a_6924_6400.t21 VSS 0.17698f
C400 a_6924_6400.n8 VSS 0.5747f
C401 a_6924_6400.n9 VSS 0.16491f
C402 a_6924_6400.t20 VSS 0.17698f
C403 a_6924_6400.t19 VSS 0.17698f
C404 a_6924_6400.n10 VSS 0.5747f
C405 a_6924_6400.n11 VSS 0.16491f
C406 a_6924_6400.t18 VSS 0.17698f
C407 a_6924_6400.t17 VSS 0.17698f
C408 a_6924_6400.n12 VSS 0.5747f
C409 a_6924_6400.n13 VSS 0.16491f
C410 a_6924_6400.t16 VSS 0.77033f
C411 a_6924_6400.n14 VSS 0.34118f
C412 a_6924_6400.n15 VSS 0.05313f
C413 a_6924_6400.n16 VSS 0.06306f
C414 a_6924_6400.n17 VSS 0.06306f
C415 a_6924_6400.n18 VSS 0.06306f
C416 a_6924_6400.n19 VSS 0.06306f
C417 a_6924_6400.n20 VSS 0.06306f
C418 a_6924_6400.n21 VSS 0.06306f
C419 a_6924_6400.n22 VSS 0.06306f
C420 a_6924_6400.n23 VSS 0.06306f
C421 a_6924_6400.n24 VSS 0.06306f
C422 a_6924_6400.n25 VSS 0.06306f
C423 a_6924_6400.n26 VSS 0.06306f
C424 a_6924_6400.n27 VSS 0.06306f
C425 a_6924_6400.n28 VSS 0.18353f
C426 a_6924_6400.n29 VSS 0.09071f
C427 a_6924_6400.n30 VSS 0.09724f
C428 a_6924_6400.n31 VSS 0.09724f
C429 a_6924_6400.n32 VSS 0.09724f
C430 a_6924_6400.n33 VSS 0.09724f
C431 a_6924_6400.n34 VSS 0.09724f
C432 a_6924_6400.n35 VSS 0.09724f
C433 a_6924_6400.n36 VSS 0.09724f
C434 a_6924_6400.n37 VSS 0.09724f
C435 a_6924_6400.n38 VSS 0.09724f
C436 a_6924_6400.n39 VSS 0.09724f
C437 a_6924_6400.n40 VSS 0.09724f
C438 a_6924_6400.n41 VSS 0.09724f
C439 a_6924_6400.n42 VSS 0.09724f
C440 a_6924_6400.n43 VSS 0.09724f
C441 a_6924_6400.n44 VSS 0.09724f
C442 a_6924_6400.n45 VSS 0.06306f
C443 a_6924_6400.n46 VSS 0.09724f
C444 a_6924_6400.n47 VSS 0.06306f
C445 a_6924_6400.n48 VSS 0.09724f
C446 a_6924_6400.n49 VSS 0.06306f
C447 a_6924_6400.n50 VSS 0.09724f
C448 a_6924_6400.n51 VSS 0.09071f
C449 a_6924_6400.n52 VSS 0.18353f
C450 a_6924_6400.n53 VSS 0.09724f
C451 a_6924_6400.n54 VSS 0.09724f
C452 a_6924_6400.n55 VSS 0.09724f
C453 a_6924_6400.n56 VSS 0.06306f
C454 a_6924_6400.n57 VSS 0.06306f
C455 a_6924_6400.n58 VSS 0.06306f
C456 a_6924_6400.n59 VSS 0.09724f
C457 a_6924_6400.n60 VSS 0.09724f
C458 a_6924_6400.n61 VSS 0.09724f
C459 a_6924_6400.n62 VSS 0.06306f
C460 a_6924_6400.n63 VSS 0.06306f
C461 a_6924_6400.n64 VSS 0.06306f
C462 a_6924_6400.n65 VSS 0.09724f
C463 a_6924_6400.n66 VSS 0.09724f
C464 a_6924_6400.n67 VSS 0.09724f
C465 a_6924_6400.n68 VSS 0.06306f
C466 a_6924_6400.n69 VSS 0.06306f
C467 a_6924_6400.n70 VSS 0.06306f
C468 a_6924_6400.n71 VSS 0.09724f
C469 a_6924_6400.n72 VSS 0.09724f
C470 a_6924_6400.n73 VSS 0.09724f
C471 a_6924_6400.n74 VSS 0.05313f
C472 a_6924_6400.n75 VSS 0.99092f
C473 a_6924_6400.n76 VSS 0.05313f
C474 a_6924_6400.n77 VSS 0.06306f
C475 a_6924_6400.n78 VSS 0.06306f
C476 a_6924_6400.n79 VSS 0.06306f
C477 a_6924_6400.n80 VSS 0.06306f
C478 a_6924_6400.n81 VSS 0.06306f
C479 a_6924_6400.n82 VSS 0.06306f
C480 a_6924_6400.n83 VSS 0.06306f
C481 a_6924_6400.n84 VSS 0.06306f
C482 a_6924_6400.n85 VSS 0.06306f
C483 a_6924_6400.n86 VSS 0.06306f
C484 a_6924_6400.n87 VSS 0.06306f
C485 a_6924_6400.n88 VSS 0.06306f
C486 a_6924_6400.n89 VSS 0.18353f
C487 a_6924_6400.n90 VSS 0.09071f
C488 a_6924_6400.n91 VSS 0.09724f
C489 a_6924_6400.n92 VSS 0.09724f
C490 a_6924_6400.n93 VSS 0.09724f
C491 a_6924_6400.n94 VSS 0.09724f
C492 a_6924_6400.n95 VSS 0.09724f
C493 a_6924_6400.n96 VSS 0.09724f
C494 a_6924_6400.n97 VSS 0.09724f
C495 a_6924_6400.n98 VSS 0.09724f
C496 a_6924_6400.n99 VSS 0.09724f
C497 a_6924_6400.n100 VSS 0.09724f
C498 a_6924_6400.n101 VSS 0.09724f
C499 a_6924_6400.n102 VSS 0.09724f
C500 a_6924_6400.n103 VSS 0.09724f
C501 a_6924_6400.n104 VSS 0.09724f
C502 a_6924_6400.n105 VSS 0.09724f
C503 a_6924_6400.n106 VSS 0.06306f
C504 a_6924_6400.n107 VSS 0.09724f
C505 a_6924_6400.n108 VSS 0.06306f
C506 a_6924_6400.n109 VSS 0.09724f
C507 a_6924_6400.n110 VSS 0.06306f
C508 a_6924_6400.n111 VSS 0.09724f
C509 a_6924_6400.n112 VSS 0.09071f
C510 a_6924_6400.n113 VSS 0.18353f
C511 a_6924_6400.n114 VSS 0.09724f
C512 a_6924_6400.n115 VSS 0.09724f
C513 a_6924_6400.n116 VSS 0.09724f
C514 a_6924_6400.n117 VSS 0.06306f
C515 a_6924_6400.n118 VSS 0.06306f
C516 a_6924_6400.n119 VSS 0.06306f
C517 a_6924_6400.n120 VSS 0.09724f
C518 a_6924_6400.n121 VSS 0.09724f
C519 a_6924_6400.n122 VSS 0.09724f
C520 a_6924_6400.n123 VSS 0.06306f
C521 a_6924_6400.n124 VSS 0.06306f
C522 a_6924_6400.n125 VSS 0.06306f
C523 a_6924_6400.n126 VSS 0.09724f
C524 a_6924_6400.n127 VSS 0.09724f
C525 a_6924_6400.n128 VSS 0.09724f
C526 a_6924_6400.n129 VSS 0.06306f
C527 a_6924_6400.n130 VSS 0.06306f
C528 a_6924_6400.n131 VSS 0.06306f
C529 a_6924_6400.n132 VSS 0.09724f
C530 a_6924_6400.n133 VSS 0.09724f
C531 a_6924_6400.n134 VSS 0.09724f
C532 a_6924_6400.n135 VSS 0.05313f
C533 a_6924_6400.n136 VSS 0.7909f
C534 a_6924_6400.n137 VSS 3.7383f
C535 a_6924_6400.n138 VSS 2.58064f
C536 a_6924_6400.t0 VSS 0.76895f
C537 a_6924_6400.n139 VSS 0.23134f
C538 a_6924_6400.t2 VSS 0.17698f
C539 a_6924_6400.t1 VSS 0.17698f
C540 a_6924_6400.n140 VSS 0.57047f
C541 a_6924_6400.n141 VSS 0.16914f
C542 a_6924_6400.t4 VSS 0.17698f
C543 a_6924_6400.t3 VSS 0.17698f
C544 a_6924_6400.n142 VSS 0.57047f
C545 a_6924_6400.n143 VSS 0.16914f
C546 a_6924_6400.t6 VSS 0.17698f
C547 a_6924_6400.t5 VSS 0.17698f
C548 a_6924_6400.n144 VSS 0.57047f
C549 a_6924_6400.n145 VSS 0.16914f
C550 a_6924_6400.t8 VSS 0.17698f
C551 a_6924_6400.t7 VSS 0.17698f
C552 a_6924_6400.n146 VSS 0.57047f
C553 a_6924_6400.n147 VSS 0.16914f
C554 a_6924_6400.t10 VSS 0.17698f
C555 a_6924_6400.t9 VSS 0.17698f
C556 a_6924_6400.n148 VSS 0.57047f
C557 a_6924_6400.n149 VSS 0.16914f
C558 a_6924_6400.t12 VSS 0.17698f
C559 a_6924_6400.t11 VSS 0.17698f
C560 a_6924_6400.n150 VSS 0.57047f
C561 a_6924_6400.n151 VSS 0.16914f
C562 a_6924_6400.t14 VSS 0.17698f
C563 a_6924_6400.t13 VSS 0.17698f
C564 a_6924_6400.n152 VSS 0.57047f
C565 a_6924_6400.n153 VSS 0.32151f
C566 a_6924_6400.t15 VSS 0.77412f
C567 VSS.t279 VSS 0.09687f
C568 VSS.t33 VSS 0.09872f
C569 VSS.t59 VSS 0.09687f
C570 VSS.t13 VSS 0.09687f
C571 VSS.t151 VSS 0.09687f
C572 VSS.t61 VSS 0.09687f
C573 VSS.t113 VSS 0.09872f
C574 VSS.t271 VSS 0.09687f
C575 VSS.t111 VSS 0.09438f
C576 VSS.t93 VSS 0.09619f
C577 VSS.t1 VSS 0.09438f
C578 VSS.t265 VSS 0.09438f
C579 VSS.t285 VSS 0.09438f
C580 VSS.t51 VSS 0.09438f
C581 VSS.t77 VSS 0.09438f
C582 VSS.t283 VSS 0.09438f
C583 VSS.t277 VSS 0.09438f
C584 VSS.t75 VSS 0.09438f
C585 VSS.t81 VSS 0.09438f
C586 VSS.t275 VSS 0.09438f
C587 VSS.t149 VSS 0.09438f
C588 VSS.t79 VSS 0.09438f
C589 VSS.t135 VSS 0.09438f
C590 VSS.t147 VSS 0.09438f
C591 VSS.t139 VSS 0.09438f
C592 VSS.t133 VSS 0.09438f
C593 VSS.t5 VSS 0.09438f
C594 VSS.t137 VSS 0.09438f
C595 VSS.t55 VSS 0.09438f
C596 VSS.t3 VSS 0.09438f
C597 VSS.t49 VSS 0.09438f
C598 VSS.t53 VSS 0.09438f
C599 VSS.t25 VSS 0.09438f
C600 VSS.t47 VSS 0.09438f
C601 VSS.t107 VSS 0.09438f
C602 VSS.t23 VSS 0.09438f
C603 VSS.t9 VSS 0.09438f
C604 VSS.t105 VSS 0.09438f
C605 VSS.t57 VSS 0.09619f
C606 VSS.t7 VSS 0.09438f
C607 VSS.t273 VSS 0.0967f
C608 VSS.t21 VSS 0.09855f
C609 VSS.t103 VSS 0.0967f
C610 VSS.t281 VSS 0.0967f
C611 VSS.t167 VSS 0.0967f
C612 VSS.t39 VSS 0.0967f
C613 VSS.t19 VSS 0.09855f
C614 VSS.t165 VSS 0.0967f
C615 VSS.t227 VSS 0.06595f
C616 VSS.t237 VSS 0.06722f
C617 VSS.t239 VSS 0.06595f
C618 VSS.t241 VSS 0.06595f
C619 VSS.t245 VSS 0.06595f
C620 VSS.t243 VSS 0.06595f
C621 VSS.t249 VSS 0.06595f
C622 VSS.t247 VSS 0.06595f
C623 VSS.t253 VSS 0.06595f
C624 VSS.t251 VSS 0.06595f
C625 VSS.t255 VSS 0.06595f
C626 VSS.t225 VSS 0.06595f
C627 VSS.t259 VSS 0.06595f
C628 VSS.t257 VSS 0.06595f
C629 VSS.t263 VSS 0.06722f
C630 VSS.t261 VSS 0.06595f
C631 VSS.t231 VSS 0.06595f
C632 VSS.t229 VSS 0.06722f
C633 VSS.t235 VSS 0.06722f
C634 VSS.t233 VSS 0.06595f
C635 VSS.t173 VSS 0.06409f
C636 VSS.t171 VSS 0.06532f
C637 VSS.t175 VSS 0.06532f
C638 VSS.t169 VSS 0.06409f
C639 VSS.t219 VSS 0.06169f
C640 VSS.t221 VSS 0.06287f
C641 VSS.t223 VSS 0.06287f
C642 VSS.t217 VSS 0.06169f
C643 VSS.t89 VSS 0.09687f
C644 VSS.t35 VSS 0.09872f
C645 VSS.t145 VSS 0.09687f
C646 VSS.t87 VSS 0.09687f
C647 VSS.t99 VSS 0.09687f
C648 VSS.t143 VSS 0.09687f
C649 VSS.t287 VSS 0.09872f
C650 VSS.t97 VSS 0.09687f
C651 VSS.t109 VSS 0.09438f
C652 VSS.t63 VSS 0.09619f
C653 VSS.t41 VSS 0.09438f
C654 VSS.t71 VSS 0.09438f
C655 VSS.t27 VSS 0.09438f
C656 VSS.t11 VSS 0.09438f
C657 VSS.t83 VSS 0.09438f
C658 VSS.t65 VSS 0.09438f
C659 VSS.t95 VSS 0.09438f
C660 VSS.t73 VSS 0.09438f
C661 VSS.t123 VSS 0.09438f
C662 VSS.t115 VSS 0.09438f
C663 VSS.t141 VSS 0.09438f
C664 VSS.t155 VSS 0.09438f
C665 VSS.t127 VSS 0.09438f
C666 VSS.t117 VSS 0.09438f
C667 VSS.t159 VSS 0.09438f
C668 VSS.t125 VSS 0.09438f
C669 VSS.t121 VSS 0.09438f
C670 VSS.t157 VSS 0.09438f
C671 VSS.t131 VSS 0.09438f
C672 VSS.t119 VSS 0.09438f
C673 VSS.t163 VSS 0.09438f
C674 VSS.t129 VSS 0.09438f
C675 VSS.t269 VSS 0.09438f
C676 VSS.t161 VSS 0.09438f
C677 VSS.t31 VSS 0.09438f
C678 VSS.t267 VSS 0.09438f
C679 VSS.t69 VSS 0.09438f
C680 VSS.t29 VSS 0.09438f
C681 VSS.t85 VSS 0.09619f
C682 VSS.t67 VSS 0.09438f
C683 VSS.t185 VSS 0.06595f
C684 VSS.t183 VSS 0.06722f
C685 VSS.t191 VSS 0.06722f
C686 VSS.t189 VSS 0.06595f
C687 VSS.t195 VSS 0.06595f
C688 VSS.t199 VSS 0.06722f
C689 VSS.t187 VSS 0.06595f
C690 VSS.t181 VSS 0.06595f
C691 VSS.t201 VSS 0.06595f
C692 VSS.t179 VSS 0.06595f
C693 VSS.t205 VSS 0.06595f
C694 VSS.t203 VSS 0.06595f
C695 VSS.t209 VSS 0.06595f
C696 VSS.t207 VSS 0.06595f
C697 VSS.t177 VSS 0.06595f
C698 VSS.t197 VSS 0.06595f
C699 VSS.t211 VSS 0.06595f
C700 VSS.t193 VSS 0.06595f
C701 VSS.t215 VSS 0.06722f
C702 VSS.t213 VSS 0.06595f
C703 VSS.t45 VSS 0.0967f
C704 VSS.t101 VSS 0.09855f
C705 VSS.t17 VSS 0.0967f
C706 VSS.t43 VSS 0.0967f
C707 VSS.t153 VSS 0.0967f
C708 VSS.t15 VSS 0.0967f
C709 VSS.t91 VSS 0.09855f
C710 VSS.t37 VSS 0.0967f
C711 VDD.n1 VSS 1.23367f
C712 VDD.n2 VSS 1.39354f
C713 VDD.n3 VSS 0.2165f
C714 VDD.n4 VSS 2.62117f
C715 VDD.t271 VSS 0.10549f
C716 VDD.t119 VSS 0.10735f
C717 VDD.n5 VSS 0.045f
C718 VDD.t83 VSS 0.10549f
C719 VDD.t259 VSS 0.10549f
C720 VDD.n6 VSS 0.04465f
C721 VDD.n7 VSS 0.02263f
C722 VDD.t43 VSS 0.10549f
C723 VDD.t41 VSS 0.10549f
C724 VDD.n8 VSS 0.04465f
C725 VDD.n9 VSS 0.01281f
C726 VDD.t85 VSS 0.10735f
C727 VDD.t67 VSS 0.10549f
C728 VDD.n10 VSS 0.04465f
C729 VDD.n11 VSS 0.05002f
C730 VDD.n12 VSS 0.78864f
C731 VDD.t251 VSS 0.10301f
C732 VDD.t273 VSS 0.10482f
C733 VDD.n13 VSS 0.045f
C734 VDD.t277 VSS 0.10301f
C735 VDD.t275 VSS 0.10301f
C736 VDD.n14 VSS 0.04465f
C737 VDD.n15 VSS 0.02263f
C738 VDD.t151 VSS 0.10301f
C739 VDD.t279 VSS 0.10301f
C740 VDD.n16 VSS 0.04465f
C741 VDD.n17 VSS 0.01281f
C742 VDD.t77 VSS 0.10301f
C743 VDD.t1 VSS 0.10301f
C744 VDD.n18 VSS 0.04465f
C745 VDD.n19 VSS 0.01281f
C746 VDD.t23 VSS 0.10301f
C747 VDD.t61 VSS 0.10301f
C748 VDD.n20 VSS 0.04465f
C749 VDD.n21 VSS 0.01281f
C750 VDD.t3 VSS 0.10301f
C751 VDD.t123 VSS 0.10301f
C752 VDD.n22 VSS 0.04465f
C753 VDD.n23 VSS 0.01281f
C754 VDD.t63 VSS 0.10301f
C755 VDD.t79 VSS 0.10301f
C756 VDD.n24 VSS 0.04465f
C757 VDD.n25 VSS 0.01281f
C758 VDD.t125 VSS 0.10301f
C759 VDD.t25 VSS 0.10301f
C760 VDD.n26 VSS 0.04465f
C761 VDD.n27 VSS 0.01281f
C762 VDD.t129 VSS 0.10301f
C763 VDD.t261 VSS 0.10301f
C764 VDD.n28 VSS 0.04465f
C765 VDD.n29 VSS 0.01281f
C766 VDD.t137 VSS 0.10301f
C767 VDD.t5 VSS 0.10301f
C768 VDD.n30 VSS 0.04465f
C769 VDD.n31 VSS 0.01281f
C770 VDD.t281 VSS 0.10301f
C771 VDD.t81 VSS 0.10301f
C772 VDD.n32 VSS 0.04465f
C773 VDD.n33 VSS 0.01281f
C774 VDD.t27 VSS 0.10301f
C775 VDD.t65 VSS 0.10301f
C776 VDD.n34 VSS 0.04465f
C777 VDD.n35 VSS 0.01281f
C778 VDD.t107 VSS 0.10301f
C779 VDD.t103 VSS 0.10301f
C780 VDD.n36 VSS 0.04465f
C781 VDD.n37 VSS 0.01281f
C782 VDD.t263 VSS 0.10301f
C783 VDD.t145 VSS 0.10301f
C784 VDD.n38 VSS 0.04465f
C785 VDD.n39 VSS 0.01281f
C786 VDD.t139 VSS 0.10301f
C787 VDD.t131 VSS 0.10301f
C788 VDD.n40 VSS 0.04465f
C789 VDD.n41 VSS 0.01281f
C790 VDD.t105 VSS 0.10482f
C791 VDD.t283 VSS 0.10301f
C792 VDD.n42 VSS 0.04465f
C793 VDD.n43 VSS 0.05002f
C794 VDD.n44 VSS 0.74103f
C795 VDD.n45 VSS 2.11056f
C796 VDD.t104 VSS 0.9736f
C797 VDD.t282 VSS 0.12011f
C798 VDD.t138 VSS 0.12011f
C799 VDD.t130 VSS 0.12011f
C800 VDD.t262 VSS 0.12011f
C801 VDD.t144 VSS 0.12011f
C802 VDD.t106 VSS 0.12011f
C803 VDD.t102 VSS 0.12011f
C804 VDD.t26 VSS 0.12011f
C805 VDD.t64 VSS 0.12011f
C806 VDD.t280 VSS 0.12011f
C807 VDD.t80 VSS 0.12011f
C808 VDD.t136 VSS 0.12011f
C809 VDD.t4 VSS 0.12011f
C810 VDD.t128 VSS 0.12011f
C811 VDD.t260 VSS 0.12011f
C812 VDD.t124 VSS 0.12011f
C813 VDD.t24 VSS 0.12011f
C814 VDD.t62 VSS 0.12011f
C815 VDD.t78 VSS 0.12011f
C816 VDD.t2 VSS 0.12011f
C817 VDD.t122 VSS 0.12011f
C818 VDD.t22 VSS 0.12011f
C819 VDD.t60 VSS 0.12011f
C820 VDD.t76 VSS 0.12011f
C821 VDD.t0 VSS 0.12011f
C822 VDD.t150 VSS 0.12011f
C823 VDD.t278 VSS 0.12011f
C824 VDD.t276 VSS 0.12011f
C825 VDD.t274 VSS 0.12011f
C826 VDD.t250 VSS 0.12011f
C827 VDD.t272 VSS 0.67261f
C828 VDD.t84 VSS 0.67261f
C829 VDD.t66 VSS 0.12011f
C830 VDD.t42 VSS 0.12011f
C831 VDD.t40 VSS 0.12011f
C832 VDD.t82 VSS 0.12011f
C833 VDD.t258 VSS 0.12011f
C834 VDD.t270 VSS 0.12011f
C835 VDD.t118 VSS 0.51947f
C836 VDD.t158 VSS 0.67321f
C837 VDD.t156 VSS 0.12011f
C838 VDD.t160 VSS 0.12011f
C839 VDD.t154 VSS 0.67261f
C840 VDD.t216 VSS 0.67261f
C841 VDD.t218 VSS 0.12011f
C842 VDD.t222 VSS 0.12011f
C843 VDD.t224 VSS 0.67261f
C844 VDD.t226 VSS 0.67261f
C845 VDD.t228 VSS 0.12011f
C846 VDD.t230 VSS 0.12011f
C847 VDD.t210 VSS 0.12011f
C848 VDD.t232 VSS 0.12011f
C849 VDD.t234 VSS 0.12011f
C850 VDD.t236 VSS 0.12011f
C851 VDD.t238 VSS 0.12011f
C852 VDD.t240 VSS 0.12011f
C853 VDD.t242 VSS 0.12011f
C854 VDD.t220 VSS 0.12011f
C855 VDD.t212 VSS 0.12011f
C856 VDD.t214 VSS 0.12011f
C857 VDD.t244 VSS 0.12011f
C858 VDD.t246 VSS 0.12011f
C859 VDD.t248 VSS 0.67261f
C860 VDD.t254 VSS 0.67261f
C861 VDD.t252 VSS 0.12011f
C862 VDD.t48 VSS 0.12011f
C863 VDD.t20 VSS 0.12011f
C864 VDD.t114 VSS 0.12011f
C865 VDD.t72 VSS 0.12011f
C866 VDD.t90 VSS 0.12011f
C867 VDD.t74 VSS 0.21319f
C868 VDD.n46 VSS 0.62107f
C869 VDD.n47 VSS 0.02465f
C870 VDD.n48 VSS 0.01841f
C871 VDD.t253 VSS 0.10532f
C872 VDD.t255 VSS 0.10718f
C873 VDD.n49 VSS 0.045f
C874 VDD.t21 VSS 0.10532f
C875 VDD.t49 VSS 0.10532f
C876 VDD.n50 VSS 0.04465f
C877 VDD.n51 VSS 0.02263f
C878 VDD.t73 VSS 0.10532f
C879 VDD.t115 VSS 0.10532f
C880 VDD.n52 VSS 0.04465f
C881 VDD.n53 VSS 0.01281f
C882 VDD.t75 VSS 0.10718f
C883 VDD.t91 VSS 0.10532f
C884 VDD.n54 VSS 0.04465f
C885 VDD.n55 VSS 0.04767f
C886 VDD.n56 VSS 0.26523f
C887 VDD.t229 VSS 0.07458f
C888 VDD.t227 VSS 0.07585f
C889 VDD.n57 VSS 0.045f
C890 VDD.t211 VSS 0.07458f
C891 VDD.t231 VSS 0.07458f
C892 VDD.n58 VSS 0.04465f
C893 VDD.n59 VSS 0.02263f
C894 VDD.t235 VSS 0.07458f
C895 VDD.t233 VSS 0.07458f
C896 VDD.n60 VSS 0.04465f
C897 VDD.n61 VSS 0.01281f
C898 VDD.t239 VSS 0.07458f
C899 VDD.t237 VSS 0.07458f
C900 VDD.n62 VSS 0.04465f
C901 VDD.n63 VSS 0.01281f
C902 VDD.t243 VSS 0.07458f
C903 VDD.t241 VSS 0.07458f
C904 VDD.n64 VSS 0.04465f
C905 VDD.n65 VSS 0.01281f
C906 VDD.t213 VSS 0.07458f
C907 VDD.t221 VSS 0.07458f
C908 VDD.n66 VSS 0.04465f
C909 VDD.n67 VSS 0.01281f
C910 VDD.t245 VSS 0.07458f
C911 VDD.t215 VSS 0.07458f
C912 VDD.n68 VSS 0.04465f
C913 VDD.n69 VSS 0.01281f
C914 VDD.t249 VSS 0.07585f
C915 VDD.t247 VSS 0.07458f
C916 VDD.n70 VSS 0.04465f
C917 VDD.n71 VSS 0.05002f
C918 VDD.n72 VSS 0.58641f
C919 VDD.t219 VSS 0.07458f
C920 VDD.t217 VSS 0.07585f
C921 VDD.n73 VSS 0.045f
C922 VDD.t225 VSS 0.07585f
C923 VDD.t223 VSS 0.07458f
C924 VDD.n74 VSS 0.04465f
C925 VDD.n75 VSS 0.05984f
C926 VDD.n76 VSS 0.53996f
C927 VDD.t157 VSS 0.07272f
C928 VDD.t159 VSS 0.07395f
C929 VDD.n77 VSS 0.045f
C930 VDD.t155 VSS 0.07395f
C931 VDD.t161 VSS 0.07272f
C932 VDD.n78 VSS 0.04465f
C933 VDD.n79 VSS 0.05984f
C934 VDD.n80 VSS 0.37987f
C935 VDD.n81 VSS 0.17934f
C936 VDD.n82 VSS 1.64194f
C937 VDD.n83 VSS 30.5348f
C938 VDD.n84 VSS 64.6393f
C939 VDD.n85 VSS 1.23367f
C940 VDD.n86 VSS 1.39354f
C941 VDD.n87 VSS 0.2165f
C942 VDD.n88 VSS 2.62117f
C943 VDD.t89 VSS 0.10549f
C944 VDD.t15 VSS 0.10735f
C945 VDD.n89 VSS 0.045f
C946 VDD.t287 VSS 0.10549f
C947 VDD.t87 VSS 0.10549f
C948 VDD.n90 VSS 0.04465f
C949 VDD.n91 VSS 0.02263f
C950 VDD.t71 VSS 0.10549f
C951 VDD.t285 VSS 0.10549f
C952 VDD.n92 VSS 0.04465f
C953 VDD.n93 VSS 0.01281f
C954 VDD.t45 VSS 0.10735f
C955 VDD.t69 VSS 0.10549f
C956 VDD.n94 VSS 0.04465f
C957 VDD.n95 VSS 0.05002f
C958 VDD.n96 VSS 0.78864f
C959 VDD.t29 VSS 0.10301f
C960 VDD.t7 VSS 0.10482f
C961 VDD.n97 VSS 0.045f
C962 VDD.t51 VSS 0.10301f
C963 VDD.t93 VSS 0.10301f
C964 VDD.n98 VSS 0.04465f
C965 VDD.n99 VSS 0.02263f
C966 VDD.t31 VSS 0.10301f
C967 VDD.t9 VSS 0.10301f
C968 VDD.n100 VSS 0.04465f
C969 VDD.n101 VSS 0.01281f
C970 VDD.t127 VSS 0.10301f
C971 VDD.t95 VSS 0.10301f
C972 VDD.n102 VSS 0.04465f
C973 VDD.n103 VSS 0.01281f
C974 VDD.t133 VSS 0.10301f
C975 VDD.t265 VSS 0.10301f
C976 VDD.n104 VSS 0.04465f
C977 VDD.n105 VSS 0.01281f
C978 VDD.t109 VSS 0.10301f
C979 VDD.t141 VSS 0.10301f
C980 VDD.n106 VSS 0.04465f
C981 VDD.n107 VSS 0.01281f
C982 VDD.t267 VSS 0.10301f
C983 VDD.t147 VSS 0.10301f
C984 VDD.n108 VSS 0.04465f
C985 VDD.n109 VSS 0.01281f
C986 VDD.t53 VSS 0.10301f
C987 VDD.t135 VSS 0.10301f
C988 VDD.n110 VSS 0.04465f
C989 VDD.n111 VSS 0.01281f
C990 VDD.t143 VSS 0.10301f
C991 VDD.t11 VSS 0.10301f
C992 VDD.n112 VSS 0.04465f
C993 VDD.n113 VSS 0.01281f
C994 VDD.t97 VSS 0.10301f
C995 VDD.t33 VSS 0.10301f
C996 VDD.n114 VSS 0.04465f
C997 VDD.n115 VSS 0.01281f
C998 VDD.t149 VSS 0.10301f
C999 VDD.t117 VSS 0.10301f
C1000 VDD.n116 VSS 0.04465f
C1001 VDD.n117 VSS 0.01281f
C1002 VDD.t35 VSS 0.10301f
C1003 VDD.t257 VSS 0.10301f
C1004 VDD.n118 VSS 0.04465f
C1005 VDD.n119 VSS 0.01281f
C1006 VDD.t269 VSS 0.10301f
C1007 VDD.t99 VSS 0.10301f
C1008 VDD.n120 VSS 0.04465f
C1009 VDD.n121 VSS 0.01281f
C1010 VDD.t37 VSS 0.10301f
C1011 VDD.t153 VSS 0.10301f
C1012 VDD.n122 VSS 0.04465f
C1013 VDD.n123 VSS 0.01281f
C1014 VDD.t55 VSS 0.10301f
C1015 VDD.t101 VSS 0.10301f
C1016 VDD.n124 VSS 0.04465f
C1017 VDD.n125 VSS 0.01281f
C1018 VDD.t39 VSS 0.10482f
C1019 VDD.t13 VSS 0.10301f
C1020 VDD.n126 VSS 0.04465f
C1021 VDD.n127 VSS 0.05002f
C1022 VDD.n128 VSS 0.74103f
C1023 VDD.n129 VSS 2.11056f
C1024 VDD.t38 VSS 0.9736f
C1025 VDD.t12 VSS 0.12011f
C1026 VDD.t54 VSS 0.12011f
C1027 VDD.t100 VSS 0.12011f
C1028 VDD.t36 VSS 0.12011f
C1029 VDD.t152 VSS 0.12011f
C1030 VDD.t268 VSS 0.12011f
C1031 VDD.t98 VSS 0.12011f
C1032 VDD.t34 VSS 0.12011f
C1033 VDD.t256 VSS 0.12011f
C1034 VDD.t148 VSS 0.12011f
C1035 VDD.t116 VSS 0.12011f
C1036 VDD.t96 VSS 0.12011f
C1037 VDD.t32 VSS 0.12011f
C1038 VDD.t142 VSS 0.12011f
C1039 VDD.t10 VSS 0.12011f
C1040 VDD.t52 VSS 0.12011f
C1041 VDD.t134 VSS 0.12011f
C1042 VDD.t266 VSS 0.12011f
C1043 VDD.t146 VSS 0.12011f
C1044 VDD.t108 VSS 0.12011f
C1045 VDD.t140 VSS 0.12011f
C1046 VDD.t132 VSS 0.12011f
C1047 VDD.t264 VSS 0.12011f
C1048 VDD.t126 VSS 0.12011f
C1049 VDD.t94 VSS 0.12011f
C1050 VDD.t30 VSS 0.12011f
C1051 VDD.t8 VSS 0.12011f
C1052 VDD.t50 VSS 0.12011f
C1053 VDD.t92 VSS 0.12011f
C1054 VDD.t28 VSS 0.12011f
C1055 VDD.t6 VSS 0.67261f
C1056 VDD.t44 VSS 0.67261f
C1057 VDD.t68 VSS 0.12011f
C1058 VDD.t70 VSS 0.12011f
C1059 VDD.t284 VSS 0.12011f
C1060 VDD.t286 VSS 0.12011f
C1061 VDD.t86 VSS 0.12011f
C1062 VDD.t88 VSS 0.12011f
C1063 VDD.t14 VSS 0.51947f
C1064 VDD.t206 VSS 0.67321f
C1065 VDD.t204 VSS 0.12011f
C1066 VDD.t202 VSS 0.12011f
C1067 VDD.t208 VSS 0.67261f
C1068 VDD.t166 VSS 0.67261f
C1069 VDD.t170 VSS 0.12011f
C1070 VDD.t172 VSS 0.12011f
C1071 VDD.t174 VSS 0.67261f
C1072 VDD.t176 VSS 0.67261f
C1073 VDD.t168 VSS 0.12011f
C1074 VDD.t178 VSS 0.12011f
C1075 VDD.t164 VSS 0.12011f
C1076 VDD.t180 VSS 0.12011f
C1077 VDD.t182 VSS 0.12011f
C1078 VDD.t184 VSS 0.12011f
C1079 VDD.t186 VSS 0.12011f
C1080 VDD.t188 VSS 0.12011f
C1081 VDD.t190 VSS 0.12011f
C1082 VDD.t162 VSS 0.12011f
C1083 VDD.t194 VSS 0.12011f
C1084 VDD.t196 VSS 0.12011f
C1085 VDD.t192 VSS 0.12011f
C1086 VDD.t198 VSS 0.12011f
C1087 VDD.t200 VSS 0.67261f
C1088 VDD.t46 VSS 0.67261f
C1089 VDD.t112 VSS 0.12011f
C1090 VDD.t110 VSS 0.12011f
C1091 VDD.t58 VSS 0.12011f
C1092 VDD.t56 VSS 0.12011f
C1093 VDD.t18 VSS 0.12011f
C1094 VDD.t16 VSS 0.12011f
C1095 VDD.t120 VSS 0.21319f
C1096 VDD.n130 VSS 0.62107f
C1097 VDD.n131 VSS 0.02465f
C1098 VDD.n132 VSS 0.01841f
C1099 VDD.t113 VSS 0.10532f
C1100 VDD.t47 VSS 0.10718f
C1101 VDD.n133 VSS 0.045f
C1102 VDD.t59 VSS 0.10532f
C1103 VDD.t111 VSS 0.10532f
C1104 VDD.n134 VSS 0.04465f
C1105 VDD.n135 VSS 0.02263f
C1106 VDD.t19 VSS 0.10532f
C1107 VDD.t57 VSS 0.10532f
C1108 VDD.n136 VSS 0.04465f
C1109 VDD.n137 VSS 0.01281f
C1110 VDD.t121 VSS 0.10718f
C1111 VDD.t17 VSS 0.10532f
C1112 VDD.n138 VSS 0.04465f
C1113 VDD.n139 VSS 0.04767f
C1114 VDD.n140 VSS 0.26523f
C1115 VDD.t169 VSS 0.07458f
C1116 VDD.t177 VSS 0.07585f
C1117 VDD.n141 VSS 0.045f
C1118 VDD.t165 VSS 0.07458f
C1119 VDD.t179 VSS 0.07458f
C1120 VDD.n142 VSS 0.04465f
C1121 VDD.n143 VSS 0.02263f
C1122 VDD.t183 VSS 0.07458f
C1123 VDD.t181 VSS 0.07458f
C1124 VDD.n144 VSS 0.04465f
C1125 VDD.n145 VSS 0.01281f
C1126 VDD.t187 VSS 0.07458f
C1127 VDD.t185 VSS 0.07458f
C1128 VDD.n146 VSS 0.04465f
C1129 VDD.n147 VSS 0.01281f
C1130 VDD.t191 VSS 0.07458f
C1131 VDD.t189 VSS 0.07458f
C1132 VDD.n148 VSS 0.04465f
C1133 VDD.n149 VSS 0.01281f
C1134 VDD.t195 VSS 0.07458f
C1135 VDD.t163 VSS 0.07458f
C1136 VDD.n150 VSS 0.04465f
C1137 VDD.n151 VSS 0.01281f
C1138 VDD.t193 VSS 0.07458f
C1139 VDD.t197 VSS 0.07458f
C1140 VDD.n152 VSS 0.04465f
C1141 VDD.n153 VSS 0.01281f
C1142 VDD.t201 VSS 0.07585f
C1143 VDD.t199 VSS 0.07458f
C1144 VDD.n154 VSS 0.04465f
C1145 VDD.n155 VSS 0.05002f
C1146 VDD.n156 VSS 0.58641f
C1147 VDD.t171 VSS 0.07458f
C1148 VDD.t167 VSS 0.07585f
C1149 VDD.n157 VSS 0.045f
C1150 VDD.t175 VSS 0.07585f
C1151 VDD.t173 VSS 0.07458f
C1152 VDD.n158 VSS 0.04465f
C1153 VDD.n159 VSS 0.05984f
C1154 VDD.n160 VSS 0.53996f
C1155 VDD.t205 VSS 0.07031f
C1156 VDD.t207 VSS 0.0715f
C1157 VDD.n161 VSS 0.045f
C1158 VDD.t209 VSS 0.0715f
C1159 VDD.t203 VSS 0.07031f
C1160 VDD.n162 VSS 0.04465f
C1161 VDD.n163 VSS 0.05984f
C1162 VDD.n164 VSS 0.37987f
C1163 VDD.n165 VSS 0.17934f
C1164 VDD.n166 VSS 1.64194f
C1165 VDD.n167 VSS 30.1148f
C1166 VDD.n168 VSS 65.0594f
C1167 VDD.n170 VSS 0.01199f
C1168 CLKN_HB.n0 VSS 0.05845f
C1169 CLKN_HB.n1 VSS 0.06356f
C1170 CLKN_HB.n2 VSS 0.06356f
C1171 CLKN_HB.n3 VSS 0.05845f
C1172 CLKN_HB.n4 VSS 0.27899f
C1173 CLKN_HB.n5 VSS 0.05845f
C1174 CLKN_HB.n6 VSS 0.06356f
C1175 CLKN_HB.n7 VSS 0.06356f
C1176 CLKN_HB.n8 VSS 0.05845f
C1177 CLKN_HB.n9 VSS 0.22548f
C1178 CLKN_HB.n10 VSS 0.96729f
C1179 CLKN_H.n0 VSS 0.03713f
C1180 CLKN_H.n1 VSS 0.04406f
C1181 CLKN_H.n2 VSS 0.04406f
C1182 CLKN_H.n3 VSS 0.04406f
C1183 CLKN_H.n4 VSS 0.04406f
C1184 CLKN_H.n5 VSS 0.12826f
C1185 CLKN_H.n6 VSS 0.06339f
C1186 CLKN_H.n7 VSS 0.06795f
C1187 CLKN_H.n8 VSS 0.06795f
C1188 CLKN_H.n9 VSS 0.06795f
C1189 CLKN_H.n10 VSS 0.06795f
C1190 CLKN_H.n11 VSS 0.06795f
C1191 CLKN_H.n12 VSS 0.06795f
C1192 CLKN_H.n13 VSS 0.06795f
C1193 CLKN_H.n14 VSS 0.04406f
C1194 CLKN_H.n15 VSS 0.06795f
C1195 CLKN_H.n16 VSS 0.06339f
C1196 CLKN_H.n17 VSS 0.12826f
C1197 CLKN_H.n18 VSS 0.06795f
C1198 CLKN_H.n19 VSS 0.06795f
C1199 CLKN_H.n20 VSS 0.06795f
C1200 CLKN_H.n21 VSS 0.04406f
C1201 CLKN_H.n22 VSS 0.04406f
C1202 CLKN_H.n23 VSS 0.04406f
C1203 CLKN_H.n24 VSS 0.06795f
C1204 CLKN_H.n25 VSS 0.06795f
C1205 CLKN_H.n26 VSS 0.06795f
C1206 CLKN_H.n27 VSS 0.03713f
C1207 CLKN_H.n28 VSS 0.37792f
C1208 CLKN_H.n29 VSS 0.03713f
C1209 CLKN_H.n30 VSS 0.04406f
C1210 CLKN_H.n31 VSS 0.04406f
C1211 CLKN_H.n32 VSS 0.04406f
C1212 CLKN_H.n33 VSS 0.04406f
C1213 CLKN_H.n34 VSS 0.12826f
C1214 CLKN_H.n35 VSS 0.06339f
C1215 CLKN_H.n36 VSS 0.06795f
C1216 CLKN_H.n37 VSS 0.06795f
C1217 CLKN_H.n38 VSS 0.06795f
C1218 CLKN_H.n39 VSS 0.06795f
C1219 CLKN_H.n40 VSS 0.06795f
C1220 CLKN_H.n41 VSS 0.06795f
C1221 CLKN_H.n42 VSS 0.06795f
C1222 CLKN_H.n43 VSS 0.04406f
C1223 CLKN_H.n44 VSS 0.06795f
C1224 CLKN_H.n45 VSS 0.06339f
C1225 CLKN_H.n46 VSS 0.12826f
C1226 CLKN_H.n47 VSS 0.06795f
C1227 CLKN_H.n48 VSS 0.06795f
C1228 CLKN_H.n49 VSS 0.06795f
C1229 CLKN_H.n50 VSS 0.04406f
C1230 CLKN_H.n51 VSS 0.04406f
C1231 CLKN_H.n52 VSS 0.04406f
C1232 CLKN_H.n53 VSS 0.06795f
C1233 CLKN_H.n54 VSS 0.06795f
C1234 CLKN_H.n55 VSS 0.06795f
C1235 CLKN_H.n56 VSS 0.03713f
C1236 CLKN_H.n57 VSS 0.28532f
C1237 CLKN_H.n58 VSS 2.19579f
C1238 CLKN_H.n59 VSS 0.06249f
C1239 CLKN_H.n60 VSS 0.06795f
C1240 CLKN_H.n61 VSS 0.06795f
C1241 CLKN_H.n62 VSS 0.06249f
C1242 CLKN_H.n63 VSS 0.2983f
C1243 CLKN_H.n64 VSS 0.06249f
C1244 CLKN_H.n65 VSS 0.06795f
C1245 CLKN_H.n66 VSS 0.06795f
C1246 CLKN_H.n67 VSS 0.06249f
C1247 CLKN_H.n68 VSS 0.24109f
C1248 CLKN_H.n69 VSS 1.78956f
C1249 CLKN_H.n70 VSS 1.87604f
C1250 O_CAPTURE_CLKB.t14 VSS 1.0448f
C1251 O_CAPTURE_CLKB.t0 VSS 0.24503f
C1252 O_CAPTURE_CLKB.t1 VSS 0.24503f
C1253 O_CAPTURE_CLKB.n0 VSS 0.7678f
C1254 O_CAPTURE_CLKB.n1 VSS 0.42204f
C1255 O_CAPTURE_CLKB.t6 VSS 0.24503f
C1256 O_CAPTURE_CLKB.t7 VSS 0.24503f
C1257 O_CAPTURE_CLKB.n2 VSS 0.7678f
C1258 O_CAPTURE_CLKB.n3 VSS 0.22031f
C1259 O_CAPTURE_CLKB.t10 VSS 0.24503f
C1260 O_CAPTURE_CLKB.t11 VSS 0.24503f
C1261 O_CAPTURE_CLKB.n4 VSS 0.7678f
C1262 O_CAPTURE_CLKB.n5 VSS 0.22031f
C1263 O_CAPTURE_CLKB.t4 VSS 1.03791f
C1264 O_CAPTURE_CLKB.n6 VSS 0.45582f
C1265 O_CAPTURE_CLKB.t12 VSS 1.04296f
C1266 O_CAPTURE_CLKB.t5 VSS 0.24503f
C1267 O_CAPTURE_CLKB.t15 VSS 0.24503f
C1268 O_CAPTURE_CLKB.n7 VSS 0.76214f
C1269 O_CAPTURE_CLKB.n8 VSS 0.42953f
C1270 O_CAPTURE_CLKB.t2 VSS 0.24503f
C1271 O_CAPTURE_CLKB.t3 VSS 0.24503f
C1272 O_CAPTURE_CLKB.n9 VSS 0.76214f
C1273 O_CAPTURE_CLKB.n10 VSS 0.22597f
C1274 O_CAPTURE_CLKB.t8 VSS 0.24503f
C1275 O_CAPTURE_CLKB.t9 VSS 0.24503f
C1276 O_CAPTURE_CLKB.n11 VSS 0.76214f
C1277 O_CAPTURE_CLKB.n12 VSS 0.22597f
C1278 O_CAPTURE_CLKB.t13 VSS 1.03606f
C1279 O_CAPTURE_CLKB.n13 VSS 0.30908f
C1280 O_CAPTURE_CLKB.n14 VSS 1.14802f
C1281 O_CAPTURE_CLK.t2 VSS 1.03637f
C1282 O_CAPTURE_CLK.t3 VSS 0.24385f
C1283 O_CAPTURE_CLK.t4 VSS 0.24385f
C1284 O_CAPTURE_CLK.n0 VSS 0.76082f
C1285 O_CAPTURE_CLK.n1 VSS 0.4182f
C1286 O_CAPTURE_CLK.t13 VSS 0.24385f
C1287 O_CAPTURE_CLK.t14 VSS 0.24385f
C1288 O_CAPTURE_CLK.n2 VSS 0.76082f
C1289 O_CAPTURE_CLK.n3 VSS 0.21831f
C1290 O_CAPTURE_CLK.t5 VSS 0.24385f
C1291 O_CAPTURE_CLK.t6 VSS 0.24385f
C1292 O_CAPTURE_CLK.n4 VSS 0.76082f
C1293 O_CAPTURE_CLK.n5 VSS 0.21831f
C1294 O_CAPTURE_CLK.t0 VSS 1.02954f
C1295 O_CAPTURE_CLK.n6 VSS 0.45168f
C1296 O_CAPTURE_CLK.t15 VSS 1.03455f
C1297 O_CAPTURE_CLK.t9 VSS 0.24385f
C1298 O_CAPTURE_CLK.t10 VSS 0.24385f
C1299 O_CAPTURE_CLK.n7 VSS 0.75521f
C1300 O_CAPTURE_CLK.n8 VSS 0.42562f
C1301 O_CAPTURE_CLK.t11 VSS 0.24385f
C1302 O_CAPTURE_CLK.t12 VSS 0.24385f
C1303 O_CAPTURE_CLK.n9 VSS 0.75521f
C1304 O_CAPTURE_CLK.n10 VSS 0.22392f
C1305 O_CAPTURE_CLK.t7 VSS 0.24385f
C1306 O_CAPTURE_CLK.t8 VSS 0.24385f
C1307 O_CAPTURE_CLK.n11 VSS 0.75521f
C1308 O_CAPTURE_CLK.n12 VSS 0.22392f
C1309 O_CAPTURE_CLK.t1 VSS 1.02772f
C1310 O_CAPTURE_CLK.n13 VSS 0.30627f
C1311 O_CAPTURE_CLK.n14 VSS 0.98286f
C1312 O_SENSE.t10 VSS 1.10819f
C1313 O_SENSE.t3 VSS 0.25302f
C1314 O_SENSE.t16 VSS 0.25302f
C1315 O_SENSE.n0 VSS 0.82115f
C1316 O_SENSE.n1 VSS 0.45136f
C1317 O_SENSE.t22 VSS 0.25302f
C1318 O_SENSE.t9 VSS 0.25302f
C1319 O_SENSE.n2 VSS 0.82115f
C1320 O_SENSE.n3 VSS 0.23562f
C1321 O_SENSE.t52 VSS 0.25302f
C1322 O_SENSE.t63 VSS 0.25302f
C1323 O_SENSE.n4 VSS 0.82115f
C1324 O_SENSE.n5 VSS 0.23562f
C1325 O_SENSE.t21 VSS 0.25302f
C1326 O_SENSE.t8 VSS 0.25302f
C1327 O_SENSE.n6 VSS 0.82115f
C1328 O_SENSE.n7 VSS 0.23562f
C1329 O_SENSE.t58 VSS 0.25302f
C1330 O_SENSE.t41 VSS 0.25302f
C1331 O_SENSE.n8 VSS 0.82115f
C1332 O_SENSE.n9 VSS 0.23562f
C1333 O_SENSE.t32 VSS 0.25302f
C1334 O_SENSE.t20 VSS 0.25302f
C1335 O_SENSE.n10 VSS 0.82115f
C1336 O_SENSE.n11 VSS 0.23562f
C1337 O_SENSE.t7 VSS 0.25302f
C1338 O_SENSE.t39 VSS 0.25302f
C1339 O_SENSE.n12 VSS 0.82115f
C1340 O_SENSE.n13 VSS 0.23562f
C1341 O_SENSE.t2 VSS 0.25302f
C1342 O_SENSE.t15 VSS 0.25302f
C1343 O_SENSE.n14 VSS 0.82115f
C1344 O_SENSE.n15 VSS 0.23562f
C1345 O_SENSE.t37 VSS 0.25302f
C1346 O_SENSE.t62 VSS 0.25302f
C1347 O_SENSE.n16 VSS 0.82115f
C1348 O_SENSE.n17 VSS 0.23562f
C1349 O_SENSE.t40 VSS 0.25302f
C1350 O_SENSE.t29 VSS 0.25302f
C1351 O_SENSE.n18 VSS 0.82115f
C1352 O_SENSE.n19 VSS 0.23562f
C1353 O_SENSE.t38 VSS 0.25302f
C1354 O_SENSE.t36 VSS 0.25302f
C1355 O_SENSE.n20 VSS 0.82115f
C1356 O_SENSE.n21 VSS 0.23562f
C1357 O_SENSE.t61 VSS 0.25302f
C1358 O_SENSE.t34 VSS 0.25302f
C1359 O_SENSE.n22 VSS 0.82115f
C1360 O_SENSE.n23 VSS 0.23562f
C1361 O_SENSE.t19 VSS 0.25302f
C1362 O_SENSE.t6 VSS 0.25302f
C1363 O_SENSE.n24 VSS 0.82115f
C1364 O_SENSE.n25 VSS 0.23562f
C1365 O_SENSE.t1 VSS 0.25302f
C1366 O_SENSE.t14 VSS 0.25302f
C1367 O_SENSE.n26 VSS 0.82115f
C1368 O_SENSE.n27 VSS 0.23562f
C1369 O_SENSE.t18 VSS 0.25302f
C1370 O_SENSE.t5 VSS 0.25302f
C1371 O_SENSE.n28 VSS 0.82115f
C1372 O_SENSE.n29 VSS 0.23562f
C1373 O_SENSE.t0 VSS 1.10082f
C1374 O_SENSE.n30 VSS 0.44577f
C1375 O_SENSE.t31 VSS 1.10623f
C1376 O_SENSE.t25 VSS 0.25302f
C1377 O_SENSE.t26 VSS 0.25302f
C1378 O_SENSE.n31 VSS 0.8151f
C1379 O_SENSE.n32 VSS 0.45937f
C1380 O_SENSE.t12 VSS 0.25302f
C1381 O_SENSE.t13 VSS 0.25302f
C1382 O_SENSE.n33 VSS 0.8151f
C1383 O_SENSE.n34 VSS 0.24168f
C1384 O_SENSE.t59 VSS 0.25302f
C1385 O_SENSE.t60 VSS 0.25302f
C1386 O_SENSE.n35 VSS 0.8151f
C1387 O_SENSE.n36 VSS 0.24168f
C1388 O_SENSE.t56 VSS 0.25302f
C1389 O_SENSE.t57 VSS 0.25302f
C1390 O_SENSE.n37 VSS 0.8151f
C1391 O_SENSE.n38 VSS 0.24168f
C1392 O_SENSE.t49 VSS 0.25302f
C1393 O_SENSE.t50 VSS 0.25302f
C1394 O_SENSE.n39 VSS 0.8151f
C1395 O_SENSE.n40 VSS 0.24168f
C1396 O_SENSE.t44 VSS 0.25302f
C1397 O_SENSE.t45 VSS 0.25302f
C1398 O_SENSE.n41 VSS 0.8151f
C1399 O_SENSE.n42 VSS 0.24168f
C1400 O_SENSE.t54 VSS 0.25302f
C1401 O_SENSE.t55 VSS 0.25302f
C1402 O_SENSE.n43 VSS 0.8151f
C1403 O_SENSE.n44 VSS 0.24168f
C1404 O_SENSE.t47 VSS 0.25302f
C1405 O_SENSE.t48 VSS 0.25302f
C1406 O_SENSE.n45 VSS 0.8151f
C1407 O_SENSE.n46 VSS 0.24168f
C1408 O_SENSE.t43 VSS 0.25302f
C1409 O_SENSE.t51 VSS 0.25302f
C1410 O_SENSE.n47 VSS 0.8151f
C1411 O_SENSE.n48 VSS 0.24168f
C1412 O_SENSE.t53 VSS 0.25302f
C1413 O_SENSE.t46 VSS 0.25302f
C1414 O_SENSE.n49 VSS 0.8151f
C1415 O_SENSE.n50 VSS 0.24168f
C1416 O_SENSE.t42 VSS 0.25302f
C1417 O_SENSE.t33 VSS 0.25302f
C1418 O_SENSE.n51 VSS 0.8151f
C1419 O_SENSE.n52 VSS 0.24168f
C1420 O_SENSE.t28 VSS 0.25302f
C1421 O_SENSE.t30 VSS 0.25302f
C1422 O_SENSE.n53 VSS 0.8151f
C1423 O_SENSE.n54 VSS 0.24168f
C1424 O_SENSE.t24 VSS 0.25302f
C1425 O_SENSE.t11 VSS 0.25302f
C1426 O_SENSE.n55 VSS 0.8151f
C1427 O_SENSE.n56 VSS 0.24168f
C1428 O_SENSE.t4 VSS 0.25302f
C1429 O_SENSE.t17 VSS 0.25302f
C1430 O_SENSE.n57 VSS 0.8151f
C1431 O_SENSE.n58 VSS 0.24168f
C1432 O_SENSE.t27 VSS 0.25302f
C1433 O_SENSE.t35 VSS 0.25302f
C1434 O_SENSE.n59 VSS 0.8151f
C1435 O_SENSE.n60 VSS 0.24168f
C1436 O_SENSE.t23 VSS 1.09885f
C1437 O_SENSE.n61 VSS 0.33783f
C1438 O_SENSE.n62 VSS 1.57128f
C1439 CLKP_HB.n0 VSS 0.06073f
C1440 CLKP_HB.n1 VSS 0.06603f
C1441 CLKP_HB.n2 VSS 0.06603f
C1442 CLKP_HB.n3 VSS 0.06073f
C1443 CLKP_HB.n4 VSS 0.28987f
C1444 CLKP_HB.n5 VSS 0.06073f
C1445 CLKP_HB.n6 VSS 0.06603f
C1446 CLKP_HB.n7 VSS 0.06603f
C1447 CLKP_HB.n8 VSS 0.06073f
C1448 CLKP_HB.n9 VSS 0.23428f
C1449 CLKP_HB.n10 VSS 0.93888f
C1450 CLKP_H.n0 VSS 0.03713f
C1451 CLKP_H.n1 VSS 0.04406f
C1452 CLKP_H.n2 VSS 0.04406f
C1453 CLKP_H.n3 VSS 0.04406f
C1454 CLKP_H.n4 VSS 0.04406f
C1455 CLKP_H.n5 VSS 0.12826f
C1456 CLKP_H.n6 VSS 0.06339f
C1457 CLKP_H.n7 VSS 0.06795f
C1458 CLKP_H.n8 VSS 0.06795f
C1459 CLKP_H.n9 VSS 0.06795f
C1460 CLKP_H.n10 VSS 0.06795f
C1461 CLKP_H.n11 VSS 0.06795f
C1462 CLKP_H.n12 VSS 0.06795f
C1463 CLKP_H.n13 VSS 0.06795f
C1464 CLKP_H.n14 VSS 0.04406f
C1465 CLKP_H.n15 VSS 0.06795f
C1466 CLKP_H.n16 VSS 0.06339f
C1467 CLKP_H.n17 VSS 0.12826f
C1468 CLKP_H.n18 VSS 0.06795f
C1469 CLKP_H.n19 VSS 0.06795f
C1470 CLKP_H.n20 VSS 0.06795f
C1471 CLKP_H.n21 VSS 0.04406f
C1472 CLKP_H.n22 VSS 0.04406f
C1473 CLKP_H.n23 VSS 0.04406f
C1474 CLKP_H.n24 VSS 0.06795f
C1475 CLKP_H.n25 VSS 0.06795f
C1476 CLKP_H.n26 VSS 0.06795f
C1477 CLKP_H.n27 VSS 0.03713f
C1478 CLKP_H.n28 VSS 0.37792f
C1479 CLKP_H.n29 VSS 0.03713f
C1480 CLKP_H.n30 VSS 0.04406f
C1481 CLKP_H.n31 VSS 0.04406f
C1482 CLKP_H.n32 VSS 0.04406f
C1483 CLKP_H.n33 VSS 0.04406f
C1484 CLKP_H.n34 VSS 0.12826f
C1485 CLKP_H.n35 VSS 0.06339f
C1486 CLKP_H.n36 VSS 0.06795f
C1487 CLKP_H.n37 VSS 0.06795f
C1488 CLKP_H.n38 VSS 0.06795f
C1489 CLKP_H.n39 VSS 0.06795f
C1490 CLKP_H.n40 VSS 0.06795f
C1491 CLKP_H.n41 VSS 0.06795f
C1492 CLKP_H.n42 VSS 0.06795f
C1493 CLKP_H.n43 VSS 0.04406f
C1494 CLKP_H.n44 VSS 0.06795f
C1495 CLKP_H.n45 VSS 0.06339f
C1496 CLKP_H.n46 VSS 0.12826f
C1497 CLKP_H.n47 VSS 0.06795f
C1498 CLKP_H.n48 VSS 0.06795f
C1499 CLKP_H.n49 VSS 0.06795f
C1500 CLKP_H.n50 VSS 0.04406f
C1501 CLKP_H.n51 VSS 0.04406f
C1502 CLKP_H.n52 VSS 0.04406f
C1503 CLKP_H.n53 VSS 0.06795f
C1504 CLKP_H.n54 VSS 0.06795f
C1505 CLKP_H.n55 VSS 0.06795f
C1506 CLKP_H.n56 VSS 0.03713f
C1507 CLKP_H.n57 VSS 0.28532f
C1508 CLKP_H.n58 VSS 2.19579f
C1509 CLKP_H.n59 VSS 0.06249f
C1510 CLKP_H.n60 VSS 0.06795f
C1511 CLKP_H.n61 VSS 0.06795f
C1512 CLKP_H.n62 VSS 0.06249f
C1513 CLKP_H.n63 VSS 0.2983f
C1514 CLKP_H.n64 VSS 0.06249f
C1515 CLKP_H.n65 VSS 0.06795f
C1516 CLKP_H.n66 VSS 0.06795f
C1517 CLKP_H.n67 VSS 0.06249f
C1518 CLKP_H.n68 VSS 0.24109f
C1519 CLKP_H.n69 VSS 1.78956f
C1520 CLKP_H.n70 VSS 1.87604f
C1521 E_CAPTURE_CLKB.t6 VSS 1.0448f
C1522 E_CAPTURE_CLKB.t7 VSS 0.24503f
C1523 E_CAPTURE_CLKB.t5 VSS 0.24503f
C1524 E_CAPTURE_CLKB.n0 VSS 0.7678f
C1525 E_CAPTURE_CLKB.n1 VSS 0.42204f
C1526 E_CAPTURE_CLKB.t8 VSS 0.24503f
C1527 E_CAPTURE_CLKB.t2 VSS 0.24503f
C1528 E_CAPTURE_CLKB.n2 VSS 0.7678f
C1529 E_CAPTURE_CLKB.n3 VSS 0.22031f
C1530 E_CAPTURE_CLKB.t4 VSS 0.24503f
C1531 E_CAPTURE_CLKB.t12 VSS 0.24503f
C1532 E_CAPTURE_CLKB.n4 VSS 0.7678f
C1533 E_CAPTURE_CLKB.n5 VSS 0.22031f
C1534 E_CAPTURE_CLKB.t13 VSS 1.03791f
C1535 E_CAPTURE_CLKB.n6 VSS 0.45582f
C1536 E_CAPTURE_CLKB.t0 VSS 1.04296f
C1537 E_CAPTURE_CLKB.t10 VSS 0.24503f
C1538 E_CAPTURE_CLKB.t11 VSS 0.24503f
C1539 E_CAPTURE_CLKB.n7 VSS 0.76214f
C1540 E_CAPTURE_CLKB.n8 VSS 0.42953f
C1541 E_CAPTURE_CLKB.t3 VSS 0.24503f
C1542 E_CAPTURE_CLKB.t9 VSS 0.24503f
C1543 E_CAPTURE_CLKB.n9 VSS 0.76214f
C1544 E_CAPTURE_CLKB.n10 VSS 0.22597f
C1545 E_CAPTURE_CLKB.t15 VSS 0.24503f
C1546 E_CAPTURE_CLKB.t14 VSS 0.24503f
C1547 E_CAPTURE_CLKB.n11 VSS 0.76214f
C1548 E_CAPTURE_CLKB.n12 VSS 0.22597f
C1549 E_CAPTURE_CLKB.t1 VSS 1.03606f
C1550 E_CAPTURE_CLKB.n13 VSS 0.30908f
C1551 E_CAPTURE_CLKB.n14 VSS 1.14802f
C1552 E_CAPTURE_CLK.t6 VSS 1.03637f
C1553 E_CAPTURE_CLK.t4 VSS 0.24385f
C1554 E_CAPTURE_CLK.t3 VSS 0.24385f
C1555 E_CAPTURE_CLK.n0 VSS 0.76082f
C1556 E_CAPTURE_CLK.n1 VSS 0.4182f
C1557 E_CAPTURE_CLK.t1 VSS 0.24385f
C1558 E_CAPTURE_CLK.t5 VSS 0.24385f
C1559 E_CAPTURE_CLK.n2 VSS 0.76082f
C1560 E_CAPTURE_CLK.n3 VSS 0.21831f
C1561 E_CAPTURE_CLK.t12 VSS 0.24385f
C1562 E_CAPTURE_CLK.t14 VSS 0.24385f
C1563 E_CAPTURE_CLK.n4 VSS 0.76082f
C1564 E_CAPTURE_CLK.n5 VSS 0.21831f
C1565 E_CAPTURE_CLK.t9 VSS 1.02954f
C1566 E_CAPTURE_CLK.n6 VSS 0.45168f
C1567 E_CAPTURE_CLK.t10 VSS 1.03455f
C1568 E_CAPTURE_CLK.t13 VSS 0.24385f
C1569 E_CAPTURE_CLK.t11 VSS 0.24385f
C1570 E_CAPTURE_CLK.n7 VSS 0.75521f
C1571 E_CAPTURE_CLK.n8 VSS 0.42562f
C1572 E_CAPTURE_CLK.t8 VSS 0.24385f
C1573 E_CAPTURE_CLK.t7 VSS 0.24385f
C1574 E_CAPTURE_CLK.n9 VSS 0.75521f
C1575 E_CAPTURE_CLK.n10 VSS 0.22392f
C1576 E_CAPTURE_CLK.t0 VSS 0.24385f
C1577 E_CAPTURE_CLK.t15 VSS 0.24385f
C1578 E_CAPTURE_CLK.n11 VSS 0.75521f
C1579 E_CAPTURE_CLK.n12 VSS 0.22392f
C1580 E_CAPTURE_CLK.t2 VSS 1.02772f
C1581 E_CAPTURE_CLK.n13 VSS 0.30627f
C1582 E_CAPTURE_CLK.n14 VSS 0.98286f
C1583 E_SENSE.t26 VSS 1.10819f
C1584 E_SENSE.t61 VSS 0.25302f
C1585 E_SENSE.t40 VSS 0.25302f
C1586 E_SENSE.n0 VSS 0.82115f
C1587 E_SENSE.n1 VSS 0.45136f
C1588 E_SENSE.t38 VSS 0.25302f
C1589 E_SENSE.t53 VSS 0.25302f
C1590 E_SENSE.n2 VSS 0.82115f
C1591 E_SENSE.n3 VSS 0.23562f
C1592 E_SENSE.t41 VSS 0.25302f
C1593 E_SENSE.t31 VSS 0.25302f
C1594 E_SENSE.n4 VSS 0.82115f
C1595 E_SENSE.n5 VSS 0.23562f
C1596 E_SENSE.t25 VSS 0.25302f
C1597 E_SENSE.t10 VSS 0.25302f
C1598 E_SENSE.n6 VSS 0.82115f
C1599 E_SENSE.n7 VSS 0.23562f
C1600 E_SENSE.t15 VSS 0.25302f
C1601 E_SENSE.t60 VSS 0.25302f
C1602 E_SENSE.n8 VSS 0.82115f
C1603 E_SENSE.n9 VSS 0.23562f
C1604 E_SENSE.t20 VSS 0.25302f
C1605 E_SENSE.t39 VSS 0.25302f
C1606 E_SENSE.n10 VSS 0.82115f
C1607 E_SENSE.n11 VSS 0.23562f
C1608 E_SENSE.t2 VSS 0.25302f
C1609 E_SENSE.t37 VSS 0.25302f
C1610 E_SENSE.n12 VSS 0.82115f
C1611 E_SENSE.n13 VSS 0.23562f
C1612 E_SENSE.t52 VSS 0.25302f
C1613 E_SENSE.t36 VSS 0.25302f
C1614 E_SENSE.n14 VSS 0.82115f
C1615 E_SENSE.n15 VSS 0.23562f
C1616 E_SENSE.t9 VSS 0.25302f
C1617 E_SENSE.t14 VSS 0.25302f
C1618 E_SENSE.n16 VSS 0.82115f
C1619 E_SENSE.n17 VSS 0.23562f
C1620 E_SENSE.t19 VSS 0.25302f
C1621 E_SENSE.t1 VSS 0.25302f
C1622 E_SENSE.n18 VSS 0.82115f
C1623 E_SENSE.n19 VSS 0.23562f
C1624 E_SENSE.t33 VSS 0.25302f
C1625 E_SENSE.t8 VSS 0.25302f
C1626 E_SENSE.n20 VSS 0.82115f
C1627 E_SENSE.n21 VSS 0.23562f
C1628 E_SENSE.t13 VSS 0.25302f
C1629 E_SENSE.t18 VSS 0.25302f
C1630 E_SENSE.n22 VSS 0.82115f
C1631 E_SENSE.n23 VSS 0.23562f
C1632 E_SENSE.t0 VSS 0.25302f
C1633 E_SENSE.t43 VSS 0.25302f
C1634 E_SENSE.n24 VSS 0.82115f
C1635 E_SENSE.n25 VSS 0.23562f
C1636 E_SENSE.t59 VSS 0.25302f
C1637 E_SENSE.t58 VSS 0.25302f
C1638 E_SENSE.n26 VSS 0.82115f
C1639 E_SENSE.n27 VSS 0.23562f
C1640 E_SENSE.t57 VSS 0.25302f
C1641 E_SENSE.t50 VSS 0.25302f
C1642 E_SENSE.n28 VSS 0.82115f
C1643 E_SENSE.n29 VSS 0.23562f
C1644 E_SENSE.t56 VSS 1.10082f
C1645 E_SENSE.n30 VSS 0.44577f
C1646 E_SENSE.t24 VSS 1.10623f
C1647 E_SENSE.t6 VSS 0.25302f
C1648 E_SENSE.t7 VSS 0.25302f
C1649 E_SENSE.n31 VSS 0.8151f
C1650 E_SENSE.n32 VSS 0.45937f
C1651 E_SENSE.t34 VSS 0.25302f
C1652 E_SENSE.t35 VSS 0.25302f
C1653 E_SENSE.n33 VSS 0.8151f
C1654 E_SENSE.n34 VSS 0.24168f
C1655 E_SENSE.t11 VSS 0.25302f
C1656 E_SENSE.t12 VSS 0.25302f
C1657 E_SENSE.n35 VSS 0.8151f
C1658 E_SENSE.n36 VSS 0.24168f
C1659 E_SENSE.t16 VSS 0.25302f
C1660 E_SENSE.t17 VSS 0.25302f
C1661 E_SENSE.n37 VSS 0.8151f
C1662 E_SENSE.n38 VSS 0.24168f
C1663 E_SENSE.t22 VSS 0.25302f
C1664 E_SENSE.t23 VSS 0.25302f
C1665 E_SENSE.n39 VSS 0.8151f
C1666 E_SENSE.n40 VSS 0.24168f
C1667 E_SENSE.t4 VSS 0.25302f
C1668 E_SENSE.t5 VSS 0.25302f
C1669 E_SENSE.n41 VSS 0.8151f
C1670 E_SENSE.n42 VSS 0.24168f
C1671 E_SENSE.t46 VSS 0.25302f
C1672 E_SENSE.t47 VSS 0.25302f
C1673 E_SENSE.n43 VSS 0.8151f
C1674 E_SENSE.n44 VSS 0.24168f
C1675 E_SENSE.t44 VSS 0.25302f
C1676 E_SENSE.t45 VSS 0.25302f
C1677 E_SENSE.n45 VSS 0.8151f
C1678 E_SENSE.n46 VSS 0.24168f
C1679 E_SENSE.t48 VSS 0.25302f
C1680 E_SENSE.t49 VSS 0.25302f
C1681 E_SENSE.n47 VSS 0.8151f
C1682 E_SENSE.n48 VSS 0.24168f
C1683 E_SENSE.t29 VSS 0.25302f
C1684 E_SENSE.t30 VSS 0.25302f
C1685 E_SENSE.n49 VSS 0.8151f
C1686 E_SENSE.n50 VSS 0.24168f
C1687 E_SENSE.t54 VSS 0.25302f
C1688 E_SENSE.t55 VSS 0.25302f
C1689 E_SENSE.n51 VSS 0.8151f
C1690 E_SENSE.n52 VSS 0.24168f
C1691 E_SENSE.t27 VSS 0.25302f
C1692 E_SENSE.t28 VSS 0.25302f
C1693 E_SENSE.n53 VSS 0.8151f
C1694 E_SENSE.n54 VSS 0.24168f
C1695 E_SENSE.t62 VSS 0.25302f
C1696 E_SENSE.t63 VSS 0.25302f
C1697 E_SENSE.n55 VSS 0.8151f
C1698 E_SENSE.n56 VSS 0.24168f
C1699 E_SENSE.t21 VSS 0.25302f
C1700 E_SENSE.t3 VSS 0.25302f
C1701 E_SENSE.n57 VSS 0.8151f
C1702 E_SENSE.n58 VSS 0.24168f
C1703 E_SENSE.t51 VSS 0.25302f
C1704 E_SENSE.t42 VSS 0.25302f
C1705 E_SENSE.n59 VSS 0.8151f
C1706 E_SENSE.n60 VSS 0.24168f
C1707 E_SENSE.t32 VSS 1.09885f
C1708 E_SENSE.n61 VSS 0.33783f
C1709 E_SENSE.n62 VSS 1.57128f
.ends
