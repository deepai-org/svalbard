* PEX produced using /foss/tools/sak/sak-pex.sh with m=3 and s=1 (extresist threshold=0 mOhm, minres=1 mOhm, mindelay=0 ps)
* NGSPICE file created from local_clock_fanout_pex.ext - technology: gf180mcuD

.subckt local_clock_fanout_pex CLKP_H CLKP_HB CLKN_H CLKN_HB VDD VSS E_SENSE E_CAPTURE_CLK
+ E_CAPTURE_CLKB O_SENSE O_CAPTURE_CLK O_CAPTURE_CLKB
X0 VSS.t129 a_2700_41600.t15 O_CAPTURE_CLKB.t15 VSS.t128 nfet_03v3 ad=2.08p pd=8.52u as=3.52p ps=16.88u w=8u l=0.28u
X1 E_CAPTURE_CLKB.t12 a_2700_6400.t10 VSS.t151 VSS.t150 nfet_03v3 ad=2.08p pd=8.52u as=2.08p ps=8.52u w=8u l=0.28u
X2 VDD.t169 a_14860_41600.t93 O_SENSE.t53 VDD.t168 pfet_03v3 ad=2.08p pd=8.52u as=2.08p ps=8.52u w=8u l=0.28u
X3 a_6924_41600.t5 CLKN_HB.t0 VSS.t197 VSS.t196 nfet_03v3 ad=3.52p pd=16.88u as=2.08p ps=8.52u w=8u l=0.28u
X4 VDD.t9 a_2700_6400.t19 E_CAPTURE_CLKB.t0 VDD.t8 pfet_03v3 ad=2.08p pd=8.52u as=2.08p ps=8.52u w=8u l=0.28u
X5 VDD.t225 a_14860_6400.t73 E_SENSE.t2 VDD.t224 pfet_03v3 ad=2.08p pd=8.52u as=2.08p ps=8.52u w=8u l=0.28u
X6 VDD.t43 a_2700_41600.t21 O_CAPTURE_CLKB.t5 VDD.t42 pfet_03v3 ad=2.08p pd=8.52u as=2.08p ps=8.52u w=8u l=0.28u
X7 VSS.t3 a_6924_6400.t21 a_14860_6400.t1 VSS.t2 nfet_03v3 ad=2.08p pd=8.52u as=2.08p ps=8.52u w=8u l=0.28u
X8 O_SENSE.t7 a_14860_41600.t78 VDD.t25 VDD.t24 pfet_03v3 ad=2.08p pd=8.52u as=2.08p ps=8.52u w=8u l=0.28u
X9 VSS.t89 a_14860_41600.t35 O_SENSE.t30 VSS.t88 nfet_03v3 ad=2.08p pd=8.52u as=2.08p ps=8.52u w=8u l=0.28u
X10 E_SENSE.t40 a_14860_6400.t32 VSS.t279 VSS.t278 nfet_03v3 ad=3.52p pd=16.88u as=2.08p ps=8.52u w=8u l=0.28u
X11 O_CAPTURE_CLKB.t10 a_2700_41600.t12 VSS.t115 VSS.t114 nfet_03v3 ad=2.08p pd=8.52u as=2.08p ps=8.52u w=8u l=0.28u
X12 a_14860_6400.t16 a_6924_6400.t38 VDD.t135 VDD.t134 pfet_03v3 ad=2.08p pd=8.52u as=2.08p ps=8.52u w=8u l=0.28u
X13 VSS.t149 a_6924_6400.t19 a_14860_6400.t23 VSS.t148 nfet_03v3 ad=2.08p pd=8.52u as=2.08p ps=8.52u w=8u l=0.28u
X14 VSS.t169 CLKP_HB.t3 a_6924_6400.t2 VSS.t168 nfet_03v3 ad=2.08p pd=8.52u as=2.08p ps=8.52u w=8u l=0.28u
X15 VDD.t49 a_14860_41600.t65 O_SENSE.t17 VDD.t48 pfet_03v3 ad=2.08p pd=8.52u as=2.08p ps=8.52u w=8u l=0.28u
X16 a_6924_6400.t7 CLKP_HB.t14 VDD.t185 VDD.t184 pfet_03v3 ad=2.08p pd=8.52u as=2.08p ps=8.52u w=8u l=0.28u
X17 a_14860_6400.t20 a_6924_6400.t36 VDD.t145 VDD.t144 pfet_03v3 ad=2.08p pd=8.52u as=2.08p ps=8.52u w=8u l=0.28u
X18 VDD.t301 a_14860_6400.t65 E_SENSE.t56 VDD.t300 pfet_03v3 ad=2.08p pd=8.52u as=2.08p ps=8.52u w=8u l=0.28u
X19 VDD.t253 a_14860_41600.t87 O_SENSE.t62 VDD.t252 pfet_03v3 ad=2.08p pd=8.52u as=2.08p ps=8.52u w=8u l=0.28u
X20 O_SENSE.t6 a_14860_41600.t32 VSS.t9 VSS.t8 nfet_03v3 ad=3.52p pd=16.88u as=2.08p ps=8.52u w=8u l=0.28u
X21 VSS.t211 a_4812_6400.t15 E_CAPTURE_CLK.t11 VSS.t210 nfet_03v3 ad=2.08p pd=8.52u as=3.52p ps=16.88u w=8u l=0.28u
X22 O_SENSE.t57 a_14860_41600.t54 VSS.t177 VSS.t176 nfet_03v3 ad=2.08p pd=8.52u as=2.08p ps=8.52u w=8u l=0.28u
X23 O_SENSE.t35 a_14860_41600.t84 VDD.t75 VDD.t74 pfet_03v3 ad=2.08p pd=8.52u as=2.08p ps=8.52u w=8u l=0.28u
X24 VDD.t183 CLKP_HB.t15 a_6924_6400.t6 VDD.t182 pfet_03v3 ad=2.08p pd=8.52u as=3.52p ps=16.88u w=8u l=0.28u
X25 VSS.t299 a_14860_6400.t53 E_SENSE.t60 VSS.t298 nfet_03v3 ad=2.08p pd=8.52u as=2.08p ps=8.52u w=8u l=0.28u
X26 E_SENSE.t57 a_14860_6400.t66 VDD.t303 VDD.t302 pfet_03v3 ad=2.08p pd=8.52u as=2.08p ps=8.52u w=8u l=0.28u
X27 VSS.t133 a_14860_41600.t51 O_SENSE.t47 VSS.t132 nfet_03v3 ad=2.08p pd=8.52u as=2.08p ps=8.52u w=8u l=0.28u
X28 VDD.t311 a_6924_6400.t31 a_14860_6400.t31 VDD.t310 pfet_03v3 ad=2.08p pd=8.52u as=2.08p ps=8.52u w=8u l=0.28u
X29 a_14860_6400.t10 a_6924_6400.t12 VSS.t109 VSS.t108 nfet_03v3 ad=3.52p pd=16.88u as=2.08p ps=8.52u w=8u l=0.28u
X30 O_CAPTURE_CLK.t11 a_4812_41600.t16 VDD.t59 VDD.t58 pfet_03v3 ad=3.52p pd=16.88u as=2.08p ps=8.52u w=8u l=0.28u
X31 O_SENSE.t14 a_14860_41600.t38 VSS.t35 VSS.t34 nfet_03v3 ad=2.08p pd=8.52u as=2.08p ps=8.52u w=8u l=0.28u
X32 a_14860_41600.t23 a_6924_41600.t26 VSS.t253 VSS.t252 nfet_03v3 ad=2.08p pd=8.52u as=2.08p ps=8.52u w=8u l=0.28u
X33 VDD.t155 a_6924_6400.t29 a_14860_6400.t25 VDD.t154 pfet_03v3 ad=2.08p pd=8.52u as=2.08p ps=8.52u w=8u l=0.28u
X34 E_SENSE.t12 a_14860_6400.t54 VSS.t213 VSS.t212 nfet_03v3 ad=2.08p pd=8.52u as=2.08p ps=8.52u w=8u l=0.28u
X35 E_CAPTURE_CLK.t10 a_4812_6400.t10 VSS.t209 VSS.t208 nfet_03v3 ad=2.08p pd=8.52u as=2.08p ps=8.52u w=8u l=0.28u
X36 VDD.t295 a_14860_6400.t95 E_SENSE.t53 VDD.t294 pfet_03v3 ad=2.08p pd=8.52u as=3.52p ps=16.88u w=8u l=0.28u
X37 E_SENSE.t34 a_14860_6400.t60 VSS.t267 VSS.t266 nfet_03v3 ad=2.08p pd=8.52u as=2.08p ps=8.52u w=8u l=0.28u
X38 a_14860_41600.t25 a_6924_41600.t40 VDD.t271 VDD.t270 pfet_03v3 ad=2.08p pd=8.52u as=2.08p ps=8.52u w=8u l=0.28u
X39 VSS.t105 a_6924_41600.t13 a_14860_41600.t8 VSS.t104 nfet_03v3 ad=2.08p pd=8.52u as=2.08p ps=8.52u w=8u l=0.28u
X40 VDD.t221 a_14860_6400.t87 E_SENSE.t0 VDD.t220 pfet_03v3 ad=2.08p pd=8.52u as=2.08p ps=8.52u w=8u l=0.28u
X41 O_CAPTURE_CLKB.t8 a_2700_41600.t18 VDD.t65 VDD.t64 pfet_03v3 ad=2.08p pd=8.52u as=2.08p ps=8.52u w=8u l=0.28u
X42 a_6924_6400.t11 CLKP_HB.t10 VDD.t193 VDD.t192 pfet_03v3 ad=3.52p pd=16.88u as=2.08p ps=8.52u w=8u l=0.28u
X43 a_14860_6400.t12 a_6924_6400.t32 VDD.t95 VDD.t94 pfet_03v3 ad=2.08p pd=8.52u as=2.08p ps=8.52u w=8u l=0.28u
X44 VSS.t55 a_2700_41600.t9 O_CAPTURE_CLKB.t6 VSS.t54 nfet_03v3 ad=2.08p pd=8.52u as=2.08p ps=8.52u w=8u l=0.28u
X45 a_14860_6400.t30 a_6924_6400.t30 VDD.t309 VDD.t308 pfet_03v3 ad=2.08p pd=8.52u as=2.08p ps=8.52u w=8u l=0.28u
X46 VSS.t207 a_4812_6400.t11 E_CAPTURE_CLK.t9 VSS.t206 nfet_03v3 ad=2.08p pd=8.52u as=2.08p ps=8.52u w=8u l=0.28u
X47 O_CAPTURE_CLK.t4 a_4812_41600.t22 VDD.t39 VDD.t38 pfet_03v3 ad=2.08p pd=8.52u as=2.08p ps=8.52u w=8u l=0.28u
X48 VDD.t141 a_6924_41600.t37 a_14860_41600.t13 VDD.t140 pfet_03v3 ad=2.08p pd=8.52u as=2.08p ps=8.52u w=8u l=0.28u
X49 O_SENSE.t16 a_14860_41600.t76 VDD.t47 VDD.t46 pfet_03v3 ad=2.08p pd=8.52u as=2.08p ps=8.52u w=8u l=0.28u
X50 E_CAPTURE_CLK.t5 a_4812_6400.t20 VDD.t105 VDD.t104 pfet_03v3 ad=2.08p pd=8.52u as=2.08p ps=8.52u w=8u l=0.28u
X51 VSS.t269 a_14860_6400.t61 E_SENSE.t35 VSS.t268 nfet_03v3 ad=2.08p pd=8.52u as=2.08p ps=8.52u w=8u l=0.28u
X52 VSS.t259 a_4812_6400.t9 E_CAPTURE_CLK.t14 VSS.t258 nfet_03v3 ad=2.08p pd=8.52u as=2.08p ps=8.52u w=8u l=0.28u
X53 a_4812_41600.t1 CLKN_H.t2 VSS.t247 VSS.t246 nfet_03v3 ad=2.08p pd=8.52u as=2.08p ps=8.52u w=8u l=0.28u
X54 E_SENSE.t1 a_14860_6400.t88 VDD.t223 VDD.t222 pfet_03v3 ad=2.08p pd=8.52u as=2.08p ps=8.52u w=8u l=0.28u
X55 VSS.t59 a_4812_41600.t13 O_CAPTURE_CLK.t8 VSS.t58 nfet_03v3 ad=2.08p pd=8.52u as=2.08p ps=8.52u w=8u l=0.28u
X56 E_SENSE.t29 a_14860_6400.t94 VDD.t275 VDD.t274 pfet_03v3 ad=2.08p pd=8.52u as=2.08p ps=8.52u w=8u l=0.28u
X57 a_4812_41600.t7 CLKN_H.t4 VDD.t261 VDD.t260 pfet_03v3 ad=3.52p pd=16.88u as=2.08p ps=8.52u w=8u l=0.28u
X58 VSS.t277 a_14860_6400.t47 E_SENSE.t39 VSS.t276 nfet_03v3 ad=2.08p pd=8.52u as=2.08p ps=8.52u w=8u l=0.28u
X59 E_CAPTURE_CLKB.t10 a_2700_6400.t12 VSS.t145 VSS.t144 nfet_03v3 ad=2.08p pd=8.52u as=2.08p ps=8.52u w=8u l=0.28u
X60 VDD.t113 a_4812_41600.t19 O_CAPTURE_CLK.t12 VDD.t112 pfet_03v3 ad=2.08p pd=8.52u as=2.08p ps=8.52u w=8u l=0.28u
X61 VDD.t63 a_14860_41600.t73 O_SENSE.t24 VDD.t62 pfet_03v3 ad=2.08p pd=8.52u as=2.08p ps=8.52u w=8u l=0.28u
X62 VSS.t179 CLKN_HB.t7 a_2700_41600.t2 VSS.t178 nfet_03v3 ad=2.08p pd=8.52u as=2.08p ps=8.52u w=8u l=0.28u
X63 a_6924_41600.t1 CLKN_HB.t4 VSS.t189 VSS.t188 nfet_03v3 ad=2.08p pd=8.52u as=2.08p ps=8.52u w=8u l=0.28u
X64 VDD.t17 a_2700_6400.t21 E_CAPTURE_CLKB.t2 VDD.t16 pfet_03v3 ad=2.08p pd=8.52u as=2.08p ps=8.52u w=8u l=0.28u
X65 VDD.t215 a_4812_6400.t21 E_CAPTURE_CLK.t7 VDD.t214 pfet_03v3 ad=2.08p pd=8.52u as=2.08p ps=8.52u w=8u l=0.28u
X66 a_2700_6400.t1 CLKP_HB.t8 VSS.t161 VSS.t160 nfet_03v3 ad=2.08p pd=8.52u as=2.08p ps=8.52u w=8u l=0.28u
X67 E_SENSE.t55 a_14860_6400.t80 VDD.t299 VDD.t298 pfet_03v3 ad=2.08p pd=8.52u as=2.08p ps=8.52u w=8u l=0.28u
X68 a_6924_41600.t9 CLKN_HB.t12 VDD.t211 VDD.t210 pfet_03v3 ad=2.08p pd=8.52u as=2.08p ps=8.52u w=8u l=0.28u
X69 VDD.t101 a_6924_41600.t43 a_14860_41600.t10 VDD.t100 pfet_03v3 ad=2.08p pd=8.52u as=3.52p ps=16.88u w=8u l=0.28u
X70 O_SENSE.t36 a_14860_41600.t82 VDD.t77 VDD.t76 pfet_03v3 ad=2.08p pd=8.52u as=2.08p ps=8.52u w=8u l=0.28u
X71 VDD.t179 CLKP_HB.t19 a_2700_6400.t4 VDD.t178 pfet_03v3 ad=2.08p pd=8.52u as=3.52p ps=16.88u w=8u l=0.28u
X72 a_2700_6400.t3 CLKP_HB.t6 VSS.t155 VSS.t154 nfet_03v3 ad=3.52p pd=16.88u as=2.08p ps=8.52u w=8u l=0.28u
X73 O_SENSE.t38 a_14860_41600.t94 VDD.t103 VDD.t102 pfet_03v3 ad=2.08p pd=8.52u as=2.08p ps=8.52u w=8u l=0.28u
X74 VSS.t191 CLKN_HB.t1 a_6924_41600.t4 VSS.t190 nfet_03v3 ad=2.08p pd=8.52u as=2.08p ps=8.52u w=8u l=0.28u
X75 VSS.t137 a_14860_41600.t49 O_SENSE.t49 VSS.t136 nfet_03v3 ad=2.08p pd=8.52u as=2.08p ps=8.52u w=8u l=0.28u
X76 VDD.t237 a_14860_6400.t83 E_SENSE.t8 VDD.t236 pfet_03v3 ad=2.08p pd=8.52u as=2.08p ps=8.52u w=8u l=0.28u
X77 E_CAPTURE_CLKB.t6 a_2700_6400.t22 VDD.t55 VDD.t54 pfet_03v3 ad=2.08p pd=8.52u as=2.08p ps=8.52u w=8u l=0.28u
X78 VDD.t277 a_14860_6400.t89 E_SENSE.t30 VDD.t276 pfet_03v3 ad=2.08p pd=8.52u as=2.08p ps=8.52u w=8u l=0.28u
X79 a_4812_6400.t3 CLKP_H.t0 VSS.t99 VSS.t98 nfet_03v3 ad=3.52p pd=16.88u as=2.08p ps=8.52u w=8u l=0.28u
X80 VDD.t229 a_14860_6400.t81 E_SENSE.t4 VDD.t228 pfet_03v3 ad=2.08p pd=8.52u as=2.08p ps=8.52u w=8u l=0.28u
X81 VDD.t3 a_14860_41600.t79 O_SENSE.t1 VDD.t2 pfet_03v3 ad=2.08p pd=8.52u as=2.08p ps=8.52u w=8u l=0.28u
X82 VSS.t119 a_14860_41600.t61 O_SENSE.t39 VSS.t118 nfet_03v3 ad=2.08p pd=8.52u as=2.08p ps=8.52u w=8u l=0.28u
X83 VSS.t117 a_2700_41600.t13 O_CAPTURE_CLKB.t11 VSS.t116 nfet_03v3 ad=2.08p pd=8.52u as=2.08p ps=8.52u w=8u l=0.28u
X84 VSS.t159 CLKP_HB.t7 a_2700_6400.t2 VSS.t158 nfet_03v3 ad=2.08p pd=8.52u as=2.08p ps=8.52u w=8u l=0.28u
X85 VDD.t165 a_14860_41600.t91 O_SENSE.t51 VDD.t164 pfet_03v3 ad=2.08p pd=8.52u as=2.08p ps=8.52u w=8u l=0.28u
X86 O_SENSE.t12 a_14860_41600.t46 VSS.t31 VSS.t30 nfet_03v3 ad=2.08p pd=8.52u as=2.08p ps=8.52u w=8u l=0.28u
X87 E_SENSE.t16 a_14860_6400.t40 VSS.t221 VSS.t220 nfet_03v3 ad=2.08p pd=8.52u as=2.08p ps=8.52u w=8u l=0.28u
X88 VSS.t93 CLKP_H.t3 a_4812_6400.t0 VSS.t92 nfet_03v3 ad=2.08p pd=8.52u as=3.52p ps=16.88u w=8u l=0.28u
X89 VSS.t49 a_14860_41600.t33 O_SENSE.t20 VSS.t48 nfet_03v3 ad=2.08p pd=8.52u as=2.08p ps=8.52u w=8u l=0.28u
X90 VSS.t97 CLKP_H.t1 a_4812_6400.t2 VSS.t96 nfet_03v3 ad=2.08p pd=8.52u as=2.08p ps=8.52u w=8u l=0.28u
X91 VSS.t81 a_14860_41600.t55 O_SENSE.t26 VSS.t80 nfet_03v3 ad=2.08p pd=8.52u as=2.08p ps=8.52u w=8u l=0.28u
X92 a_4812_6400.t5 CLKP_H.t6 VDD.t83 VDD.t82 pfet_03v3 ad=2.08p pd=8.52u as=2.08p ps=8.52u w=8u l=0.28u
X93 a_2700_41600.t5 CLKN_HB.t18 VDD.t197 VDD.t196 pfet_03v3 ad=2.08p pd=8.52u as=2.08p ps=8.52u w=8u l=0.28u
X94 VDD.t149 a_6924_41600.t35 a_14860_41600.t15 VDD.t148 pfet_03v3 ad=2.08p pd=8.52u as=2.08p ps=8.52u w=8u l=0.28u
X95 VDD.t57 a_14860_41600.t85 O_SENSE.t22 VDD.t56 pfet_03v3 ad=2.08p pd=8.52u as=2.08p ps=8.52u w=8u l=0.28u
X96 VSS.t223 a_14860_6400.t41 E_SENSE.t17 VSS.t222 nfet_03v3 ad=2.08p pd=8.52u as=2.08p ps=8.52u w=8u l=0.28u
X97 VSS.t65 a_2700_6400.t11 E_CAPTURE_CLKB.t7 VSS.t64 nfet_03v3 ad=2.08p pd=8.52u as=2.08p ps=8.52u w=8u l=0.28u
X98 E_SENSE.t3 a_14860_6400.t74 VDD.t227 VDD.t226 pfet_03v3 ad=2.08p pd=8.52u as=2.08p ps=8.52u w=8u l=0.28u
X99 O_SENSE.t48 a_14860_41600.t52 VSS.t135 VSS.t134 nfet_03v3 ad=2.08p pd=8.52u as=2.08p ps=8.52u w=8u l=0.28u
X100 a_14860_6400.t4 a_6924_6400.t22 VSS.t41 VSS.t40 nfet_03v3 ad=2.08p pd=8.52u as=2.08p ps=8.52u w=8u l=0.28u
X101 VDD.t13 a_4812_41600.t17 O_CAPTURE_CLK.t0 VDD.t12 pfet_03v3 ad=2.08p pd=8.52u as=2.08p ps=8.52u w=8u l=0.28u
X102 a_14860_41600.t5 a_6924_41600.t32 VDD.t89 VDD.t88 pfet_03v3 ad=2.08p pd=8.52u as=2.08p ps=8.52u w=8u l=0.28u
X103 VSS.t289 a_14860_6400.t33 E_SENSE.t50 VSS.t288 nfet_03v3 ad=2.08p pd=8.52u as=2.08p ps=8.52u w=8u l=0.28u
X104 VDD.t137 a_6924_6400.t39 a_14860_6400.t17 VDD.t136 pfet_03v3 ad=2.08p pd=8.52u as=2.08p ps=8.52u w=8u l=0.28u
X105 a_14860_6400.t0 a_6924_6400.t20 VSS.t1 VSS.t0 nfet_03v3 ad=2.08p pd=8.52u as=2.08p ps=8.52u w=8u l=0.28u
X106 a_6924_6400.t1 CLKP_HB.t4 VSS.t165 VSS.t164 nfet_03v3 ad=2.08p pd=8.52u as=2.08p ps=8.52u w=8u l=0.28u
X107 O_CAPTURE_CLK.t2 a_4812_41600.t8 VSS.t15 VSS.t14 nfet_03v3 ad=3.52p pd=16.88u as=2.08p ps=8.52u w=8u l=0.28u
X108 VDD.t159 a_6924_41600.t41 a_14860_41600.t17 VDD.t158 pfet_03v3 ad=2.08p pd=8.52u as=2.08p ps=8.52u w=8u l=0.28u
X109 VDD.t67 a_2700_41600.t19 O_CAPTURE_CLKB.t9 VDD.t66 pfet_03v3 ad=2.08p pd=8.52u as=2.08p ps=8.52u w=8u l=0.28u
X110 O_SENSE.t45 a_14860_41600.t68 VDD.t133 VDD.t132 pfet_03v3 ad=2.08p pd=8.52u as=2.08p ps=8.52u w=8u l=0.28u
X111 a_14860_41600.t1 a_6924_41600.t24 VSS.t13 VSS.t12 nfet_03v3 ad=2.08p pd=8.52u as=2.08p ps=8.52u w=8u l=0.28u
X112 E_SENSE.t51 a_14860_6400.t34 VSS.t291 VSS.t290 nfet_03v3 ad=2.08p pd=8.52u as=2.08p ps=8.52u w=8u l=0.28u
X113 VDD.t53 a_4812_41600.t23 O_CAPTURE_CLK.t7 VDD.t52 pfet_03v3 ad=2.08p pd=8.52u as=3.52p ps=16.88u w=8u l=0.28u
X114 O_CAPTURE_CLKB.t7 a_2700_41600.t10 VSS.t63 VSS.t62 nfet_03v3 ad=2.08p pd=8.52u as=2.08p ps=8.52u w=8u l=0.28u
X115 a_14860_6400.t26 a_6924_6400.t40 VDD.t265 VDD.t264 pfet_03v3 ad=2.08p pd=8.52u as=2.08p ps=8.52u w=8u l=0.28u
X116 VSS.t157 CLKP_HB.t5 a_6924_6400.t0 VSS.t156 nfet_03v3 ad=2.08p pd=8.52u as=3.52p ps=16.88u w=8u l=0.28u
X117 a_14860_41600.t14 a_6924_41600.t38 VDD.t143 VDD.t142 pfet_03v3 ad=2.08p pd=8.52u as=2.08p ps=8.52u w=8u l=0.28u
X118 VDD.t233 a_14860_6400.t67 E_SENSE.t6 VDD.t232 pfet_03v3 ad=2.08p pd=8.52u as=2.08p ps=8.52u w=8u l=0.28u
X119 O_CAPTURE_CLKB.t12 a_2700_41600.t16 VDD.t117 VDD.t116 pfet_03v3 ad=3.52p pd=16.88u as=2.08p ps=8.52u w=8u l=0.28u
X120 VSS.t77 a_6924_6400.t15 a_14860_6400.t7 VSS.t76 nfet_03v3 ad=2.08p pd=8.52u as=2.08p ps=8.52u w=8u l=0.28u
X121 O_CAPTURE_CLK.t9 a_4812_41600.t14 VSS.t61 VSS.t60 nfet_03v3 ad=2.08p pd=8.52u as=2.08p ps=8.52u w=8u l=0.28u
X122 VSS.t69 a_6924_41600.t21 a_14860_41600.t2 VSS.t68 nfet_03v3 ad=2.08p pd=8.52u as=2.08p ps=8.52u w=8u l=0.28u
X123 O_SENSE.t29 a_14860_41600.t44 VSS.t87 VSS.t86 nfet_03v3 ad=2.08p pd=8.52u as=2.08p ps=8.52u w=8u l=0.28u
X124 VSS.t111 a_6924_6400.t13 a_14860_6400.t11 VSS.t110 nfet_03v3 ad=2.08p pd=8.52u as=2.08p ps=8.52u w=8u l=0.28u
X125 O_CAPTURE_CLK.t13 a_4812_41600.t20 VDD.t115 VDD.t114 pfet_03v3 ad=2.08p pd=8.52u as=2.08p ps=8.52u w=8u l=0.28u
X126 E_CAPTURE_CLKB.t1 a_2700_6400.t16 VDD.t11 VDD.t10 pfet_03v3 ad=3.52p pd=16.88u as=2.08p ps=8.52u w=8u l=0.28u
X127 O_SENSE.t8 a_14860_41600.t74 VDD.t27 VDD.t26 pfet_03v3 ad=2.08p pd=8.52u as=2.08p ps=8.52u w=8u l=0.28u
X128 VSS.t215 a_14860_6400.t55 E_SENSE.t13 VSS.t214 nfet_03v3 ad=2.08p pd=8.52u as=2.08p ps=8.52u w=8u l=0.28u
X129 VSS.t281 a_14860_6400.t63 E_SENSE.t45 VSS.t280 nfet_03v3 ad=2.08p pd=8.52u as=3.52p ps=16.88u w=8u l=0.28u
X130 a_2700_41600.t7 CLKN_HB.t16 VDD.t195 VDD.t194 pfet_03v3 ad=3.52p pd=16.88u as=2.08p ps=8.52u w=8u l=0.28u
X131 a_4812_41600.t3 CLKN_H.t0 VSS.t245 VSS.t244 nfet_03v3 ad=3.52p pd=16.88u as=2.08p ps=8.52u w=8u l=0.28u
X132 E_SENSE.t7 a_14860_6400.t68 VDD.t235 VDD.t234 pfet_03v3 ad=2.08p pd=8.52u as=2.08p ps=8.52u w=8u l=0.28u
X133 VSS.t37 a_4812_41600.t11 O_CAPTURE_CLK.t5 VSS.t36 nfet_03v3 ad=2.08p pd=8.52u as=2.08p ps=8.52u w=8u l=0.28u
X134 VSS.t45 a_14860_41600.t41 O_SENSE.t18 VSS.t44 nfet_03v3 ad=2.08p pd=8.52u as=2.08p ps=8.52u w=8u l=0.28u
X135 a_14860_6400.t2 a_6924_6400.t16 VSS.t21 VSS.t20 nfet_03v3 ad=2.08p pd=8.52u as=2.08p ps=8.52u w=8u l=0.28u
X136 a_6924_6400.t5 CLKP_HB.t0 VSS.t173 VSS.t172 nfet_03v3 ad=3.52p pd=16.88u as=2.08p ps=8.52u w=8u l=0.28u
X137 VDD.t187 CLKP_HB.t11 a_6924_6400.t10 VDD.t186 pfet_03v3 ad=2.08p pd=8.52u as=2.08p ps=8.52u w=8u l=0.28u
X138 VDD.t97 a_6924_6400.t33 a_14860_6400.t13 VDD.t96 pfet_03v3 ad=2.08p pd=8.52u as=2.08p ps=8.52u w=8u l=0.28u
X139 a_14860_6400.t6 a_6924_6400.t14 VSS.t75 VSS.t74 nfet_03v3 ad=2.08p pd=8.52u as=2.08p ps=8.52u w=8u l=0.28u
X140 VDD.t131 a_14860_41600.t71 O_SENSE.t44 VDD.t130 pfet_03v3 ad=2.08p pd=8.52u as=2.08p ps=8.52u w=8u l=0.28u
X141 a_6924_41600.t3 CLKN_HB.t2 VSS.t195 VSS.t194 nfet_03v3 ad=2.08p pd=8.52u as=2.08p ps=8.52u w=8u l=0.28u
X142 O_SENSE.t50 a_14860_41600.t50 VSS.t139 VSS.t138 nfet_03v3 ad=2.08p pd=8.52u as=2.08p ps=8.52u w=8u l=0.28u
X143 VDD.t263 a_2700_6400.t17 E_CAPTURE_CLKB.t14 VDD.t262 pfet_03v3 ad=2.08p pd=8.52u as=2.08p ps=8.52u w=8u l=0.28u
X144 VSS.t153 a_6924_41600.t27 a_14860_41600.t19 VSS.t152 nfet_03v3 ad=2.08p pd=8.52u as=3.52p ps=16.88u w=8u l=0.28u
X145 E_SENSE.t14 a_14860_6400.t56 VSS.t217 VSS.t216 nfet_03v3 ad=2.08p pd=8.52u as=2.08p ps=8.52u w=8u l=0.28u
X146 E_CAPTURE_CLK.t8 a_4812_6400.t12 VSS.t205 VSS.t204 nfet_03v3 ad=2.08p pd=8.52u as=2.08p ps=8.52u w=8u l=0.28u
X147 a_14860_41600.t12 a_6924_41600.t30 VDD.t109 VDD.t108 pfet_03v3 ad=2.08p pd=8.52u as=2.08p ps=8.52u w=8u l=0.28u
X148 O_SENSE.t15 a_14860_41600.t80 VDD.t45 VDD.t44 pfet_03v3 ad=2.08p pd=8.52u as=2.08p ps=8.52u w=8u l=0.28u
X149 O_SENSE.t25 a_14860_41600.t62 VSS.t79 VSS.t78 nfet_03v3 ad=2.08p pd=8.52u as=2.08p ps=8.52u w=8u l=0.28u
X150 E_SENSE.t36 a_14860_6400.t62 VSS.t271 VSS.t270 nfet_03v3 ad=2.08p pd=8.52u as=2.08p ps=8.52u w=8u l=0.28u
X151 O_SENSE.t52 a_14860_41600.t92 VDD.t167 VDD.t166 pfet_03v3 ad=2.08p pd=8.52u as=2.08p ps=8.52u w=8u l=0.28u
X152 VSS.t199 a_14860_41600.t47 O_SENSE.t59 VSS.t198 nfet_03v3 ad=2.08p pd=8.52u as=2.08p ps=8.52u w=8u l=0.28u
X153 E_SENSE.t47 a_14860_6400.t48 VSS.t283 VSS.t282 nfet_03v3 ad=2.08p pd=8.52u as=2.08p ps=8.52u w=8u l=0.28u
X154 VSS.t53 a_2700_6400.t13 E_CAPTURE_CLKB.t4 VSS.t52 nfet_03v3 ad=2.08p pd=8.52u as=2.08p ps=8.52u w=8u l=0.28u
X155 VDD.t61 a_14860_41600.t77 O_SENSE.t23 VDD.t60 pfet_03v3 ad=2.08p pd=8.52u as=2.08p ps=8.52u w=8u l=0.28u
X156 VSS.t121 a_14860_41600.t59 O_SENSE.t43 VSS.t120 nfet_03v3 ad=2.08p pd=8.52u as=2.08p ps=8.52u w=8u l=0.28u
X157 VSS.t225 a_4812_6400.t13 E_CAPTURE_CLK.t12 VSS.t224 nfet_03v3 ad=2.08p pd=8.52u as=2.08p ps=8.52u w=8u l=0.28u
X158 E_CAPTURE_CLK.t1 a_4812_6400.t22 VDD.t31 VDD.t30 pfet_03v3 ad=2.08p pd=8.52u as=2.08p ps=8.52u w=8u l=0.28u
X159 VSS.t163 CLKP_HB.t9 a_2700_6400.t0 VSS.t162 nfet_03v3 ad=2.08p pd=8.52u as=3.52p ps=16.88u w=8u l=0.28u
X160 VDD.t199 CLKN_HB.t19 a_2700_41600.t4 VDD.t198 pfet_03v3 ad=2.08p pd=8.52u as=3.52p ps=16.88u w=8u l=0.28u
X161 a_14860_41600.t16 a_6924_41600.t36 VDD.t151 VDD.t150 pfet_03v3 ad=2.08p pd=8.52u as=2.08p ps=8.52u w=8u l=0.28u
X162 VDD.t219 a_14860_41600.t89 O_SENSE.t61 VDD.t218 pfet_03v3 ad=2.08p pd=8.52u as=2.08p ps=8.52u w=8u l=0.28u
X163 VSS.t295 a_14860_6400.t51 E_SENSE.t58 VSS.t294 nfet_03v3 ad=2.08p pd=8.52u as=2.08p ps=8.52u w=8u l=0.28u
X164 VSS.t235 a_14860_6400.t57 E_SENSE.t25 VSS.t234 nfet_03v3 ad=2.08p pd=8.52u as=2.08p ps=8.52u w=8u l=0.28u
X165 VDD.t203 CLKN_HB.t15 a_6924_41600.t6 VDD.t202 pfet_03v3 ad=2.08p pd=8.52u as=3.52p ps=16.88u w=8u l=0.28u
X166 a_2700_41600.t1 CLKN_HB.t8 VSS.t181 VSS.t180 nfet_03v3 ad=2.08p pd=8.52u as=2.08p ps=8.52u w=8u l=0.28u
X167 E_SENSE.t9 a_14860_6400.t84 VDD.t239 VDD.t238 pfet_03v3 ad=2.08p pd=8.52u as=2.08p ps=8.52u w=8u l=0.28u
X168 VSS.t285 a_14860_6400.t49 E_SENSE.t48 VSS.t284 nfet_03v3 ad=2.08p pd=8.52u as=2.08p ps=8.52u w=8u l=0.28u
X169 E_CAPTURE_CLKB.t9 a_2700_6400.t14 VSS.t113 VSS.t112 nfet_03v3 ad=2.08p pd=8.52u as=2.08p ps=8.52u w=8u l=0.28u
X170 VSS.t309 a_6924_41600.t19 a_14860_41600.t30 VSS.t308 nfet_03v3 ad=2.08p pd=8.52u as=2.08p ps=8.52u w=8u l=0.28u
X171 VSS.t175 a_14860_41600.t53 O_SENSE.t56 VSS.t174 nfet_03v3 ad=2.08p pd=8.52u as=2.08p ps=8.52u w=8u l=0.28u
X172 VDD.t19 a_2700_6400.t23 E_CAPTURE_CLKB.t3 VDD.t18 pfet_03v3 ad=2.08p pd=8.52u as=3.52p ps=16.88u w=8u l=0.28u
X173 E_SENSE.t31 a_14860_6400.t90 VDD.t279 VDD.t278 pfet_03v3 ad=2.08p pd=8.52u as=2.08p ps=8.52u w=8u l=0.28u
X174 E_SENSE.t5 a_14860_6400.t82 VDD.t231 VDD.t230 pfet_03v3 ad=2.08p pd=8.52u as=2.08p ps=8.52u w=8u l=0.28u
X175 VDD.t305 a_6924_41600.t33 a_14860_41600.t28 VDD.t304 pfet_03v3 ad=2.08p pd=8.52u as=2.08p ps=8.52u w=8u l=0.28u
X176 VDD.t73 a_14860_41600.t95 O_SENSE.t34 VDD.t72 pfet_03v3 ad=2.08p pd=8.52u as=3.52p ps=16.88u w=8u l=0.28u
X177 VSS.t123 a_4812_41600.t9 O_CAPTURE_CLK.t14 VSS.t122 nfet_03v3 ad=2.08p pd=8.52u as=2.08p ps=8.52u w=8u l=0.28u
X178 a_14860_41600.t27 a_6924_41600.t16 VSS.t265 VSS.t264 nfet_03v3 ad=2.08p pd=8.52u as=2.08p ps=8.52u w=8u l=0.28u
X179 VDD.t125 a_14860_41600.t69 O_SENSE.t41 VDD.t124 pfet_03v3 ad=2.08p pd=8.52u as=2.08p ps=8.52u w=8u l=0.28u
X180 VDD.t285 a_14860_6400.t91 E_SENSE.t41 VDD.t284 pfet_03v3 ad=2.08p pd=8.52u as=2.08p ps=8.52u w=8u l=0.28u
X181 a_4812_6400.t1 CLKP_H.t2 VSS.t95 VSS.t94 nfet_03v3 ad=2.08p pd=8.52u as=2.08p ps=8.52u w=8u l=0.28u
X182 O_CAPTURE_CLKB.t0 a_2700_41600.t22 VDD.t21 VDD.t20 pfet_03v3 ad=2.08p pd=8.52u as=2.08p ps=8.52u w=8u l=0.28u
X183 VSS.t251 a_6924_41600.t25 a_14860_41600.t22 VSS.t250 nfet_03v3 ad=2.08p pd=8.52u as=2.08p ps=8.52u w=8u l=0.28u
X184 VSS.t17 a_2700_41600.t11 O_CAPTURE_CLKB.t2 VSS.t16 nfet_03v3 ad=2.08p pd=8.52u as=2.08p ps=8.52u w=8u l=0.28u
X185 O_SENSE.t31 a_14860_41600.t36 VSS.t91 VSS.t90 nfet_03v3 ad=2.08p pd=8.52u as=2.08p ps=8.52u w=8u l=0.28u
X186 VDD.t269 a_6924_41600.t39 a_14860_41600.t24 VDD.t268 pfet_03v3 ad=2.08p pd=8.52u as=2.08p ps=8.52u w=8u l=0.28u
X187 E_SENSE.t20 a_14860_6400.t42 VSS.t227 VSS.t226 nfet_03v3 ad=2.08p pd=8.52u as=2.08p ps=8.52u w=8u l=0.28u
X188 VDD.t289 a_14860_6400.t77 E_SENSE.t43 VDD.t288 pfet_03v3 ad=2.08p pd=8.52u as=2.08p ps=8.52u w=8u l=0.28u
X189 O_SENSE.t42 a_14860_41600.t66 VDD.t127 VDD.t126 pfet_03v3 ad=2.08p pd=8.52u as=2.08p ps=8.52u w=8u l=0.28u
X190 VDD.t281 a_14860_6400.t75 E_SENSE.t32 VDD.t280 pfet_03v3 ad=2.08p pd=8.52u as=2.08p ps=8.52u w=8u l=0.28u
X191 O_SENSE.t54 a_14860_41600.t88 VDD.t171 VDD.t170 pfet_03v3 ad=2.08p pd=8.52u as=2.08p ps=8.52u w=8u l=0.28u
X192 VSS.t73 a_4812_41600.t15 O_CAPTURE_CLK.t10 VSS.t72 nfet_03v3 ad=2.08p pd=8.52u as=3.52p ps=16.88u w=8u l=0.28u
X193 a_14860_41600.t3 a_6924_41600.t22 VSS.t71 VSS.t70 nfet_03v3 ad=2.08p pd=8.52u as=2.08p ps=8.52u w=8u l=0.28u
X194 E_CAPTURE_CLK.t4 a_4812_6400.t16 VDD.t51 VDD.t50 pfet_03v3 ad=3.52p pd=16.88u as=2.08p ps=8.52u w=8u l=0.28u
X195 VSS.t43 a_6924_6400.t23 a_14860_6400.t5 VSS.t42 nfet_03v3 ad=2.08p pd=8.52u as=2.08p ps=8.52u w=8u l=0.28u
X196 VDD.t255 CLKN_H.t7 a_4812_41600.t4 VDD.t254 pfet_03v3 ad=2.08p pd=8.52u as=3.52p ps=16.88u w=8u l=0.28u
X197 VDD.t5 a_14860_41600.t75 O_SENSE.t2 VDD.t4 pfet_03v3 ad=2.08p pd=8.52u as=2.08p ps=8.52u w=8u l=0.28u
X198 O_CAPTURE_CLKB.t3 a_2700_41600.t8 VSS.t19 VSS.t18 nfet_03v3 ad=3.52p pd=16.88u as=2.08p ps=8.52u w=8u l=0.28u
X199 E_SENSE.t44 a_14860_6400.t78 VDD.t291 VDD.t290 pfet_03v3 ad=2.08p pd=8.52u as=2.08p ps=8.52u w=8u l=0.28u
X200 O_CAPTURE_CLK.t6 a_4812_41600.t12 VSS.t39 VSS.t38 nfet_03v3 ad=2.08p pd=8.52u as=2.08p ps=8.52u w=8u l=0.28u
X201 O_SENSE.t19 a_14860_41600.t42 VSS.t47 VSS.t46 nfet_03v3 ad=2.08p pd=8.52u as=2.08p ps=8.52u w=8u l=0.28u
X202 E_SENSE.t33 a_14860_6400.t76 VDD.t283 VDD.t282 pfet_03v3 ad=2.08p pd=8.52u as=2.08p ps=8.52u w=8u l=0.28u
X203 O_CAPTURE_CLK.t1 a_4812_41600.t18 VDD.t15 VDD.t14 pfet_03v3 ad=2.08p pd=8.52u as=2.08p ps=8.52u w=8u l=0.28u
X204 O_SENSE.t40 a_14860_41600.t72 VDD.t111 VDD.t110 pfet_03v3 ad=2.08p pd=8.52u as=2.08p ps=8.52u w=8u l=0.28u
X205 a_2700_41600.t3 CLKN_HB.t6 VSS.t187 VSS.t186 nfet_03v3 ad=3.52p pd=16.88u as=2.08p ps=8.52u w=8u l=0.28u
X206 VDD.t123 a_6924_6400.t43 a_14860_6400.t15 VDD.t122 pfet_03v3 ad=2.08p pd=8.52u as=3.52p ps=16.88u w=8u l=0.28u
X207 a_14860_6400.t18 a_6924_6400.t24 VSS.t141 VSS.t140 nfet_03v3 ad=2.08p pd=8.52u as=2.08p ps=8.52u w=8u l=0.28u
X208 VSS.t293 a_14860_6400.t35 E_SENSE.t52 VSS.t292 nfet_03v3 ad=2.08p pd=8.52u as=2.08p ps=8.52u w=8u l=0.28u
X209 E_SENSE.t11 a_14860_6400.t70 VDD.t243 VDD.t242 pfet_03v3 ad=2.08p pd=8.52u as=2.08p ps=8.52u w=8u l=0.28u
X210 VDD.t267 a_6924_6400.t41 a_14860_6400.t27 VDD.t266 pfet_03v3 ad=2.08p pd=8.52u as=2.08p ps=8.52u w=8u l=0.28u
X211 VSS.t5 a_14860_41600.t39 O_SENSE.t4 VSS.t4 nfet_03v3 ad=2.08p pd=8.52u as=2.08p ps=8.52u w=8u l=0.28u
X212 a_14860_41600.t9 a_6924_41600.t14 VSS.t107 VSS.t106 nfet_03v3 ad=2.08p pd=8.52u as=2.08p ps=8.52u w=8u l=0.28u
X213 O_SENSE.t60 a_14860_41600.t48 VSS.t201 VSS.t200 nfet_03v3 ad=2.08p pd=8.52u as=2.08p ps=8.52u w=8u l=0.28u
X214 E_CAPTURE_CLKB.t5 a_2700_6400.t8 VSS.t57 VSS.t56 nfet_03v3 ad=3.52p pd=16.88u as=2.08p ps=8.52u w=8u l=0.28u
X215 a_14860_6400.t14 a_6924_6400.t42 VDD.t121 VDD.t120 pfet_03v3 ad=2.08p pd=8.52u as=2.08p ps=8.52u w=8u l=0.28u
X216 E_SENSE.t61 a_14860_6400.t36 VSS.t301 VSS.t300 nfet_03v3 ad=2.08p pd=8.52u as=2.08p ps=8.52u w=8u l=0.28u
X217 VDD.t245 a_14860_6400.t71 E_SENSE.t18 VDD.t244 pfet_03v3 ad=2.08p pd=8.52u as=2.08p ps=8.52u w=8u l=0.28u
X218 a_14860_41600.t20 a_6924_41600.t28 VDD.t163 VDD.t162 pfet_03v3 ad=3.52p pd=16.88u as=2.08p ps=8.52u w=8u l=0.28u
X219 O_SENSE.t46 a_14860_41600.t60 VSS.t131 VSS.t130 nfet_03v3 ad=2.08p pd=8.52u as=2.08p ps=8.52u w=8u l=0.28u
X220 O_SENSE.t32 a_14860_41600.t90 VDD.t69 VDD.t68 pfet_03v3 ad=2.08p pd=8.52u as=2.08p ps=8.52u w=8u l=0.28u
X221 VDD.t241 a_14860_6400.t69 E_SENSE.t10 VDD.t240 pfet_03v3 ad=2.08p pd=8.52u as=2.08p ps=8.52u w=8u l=0.28u
X222 VSS.t29 a_14860_41600.t45 O_SENSE.t11 VSS.t28 nfet_03v3 ad=2.08p pd=8.52u as=2.08p ps=8.52u w=8u l=0.28u
X223 VSS.t23 a_6924_6400.t17 a_14860_6400.t3 VSS.t22 nfet_03v3 ad=2.08p pd=8.52u as=2.08p ps=8.52u w=8u l=0.28u
X224 VSS.t167 CLKP_HB.t1 a_6924_6400.t4 VSS.t166 nfet_03v3 ad=2.08p pd=8.52u as=2.08p ps=8.52u w=8u l=0.28u
X225 a_6924_6400.t9 CLKP_HB.t12 VDD.t191 VDD.t190 pfet_03v3 ad=2.08p pd=8.52u as=2.08p ps=8.52u w=8u l=0.28u
X226 a_14860_6400.t8 a_6924_6400.t34 VDD.t91 VDD.t90 pfet_03v3 ad=2.08p pd=8.52u as=2.08p ps=8.52u w=8u l=0.28u
X227 VSS.t67 a_2700_6400.t9 E_CAPTURE_CLKB.t8 VSS.t66 nfet_03v3 ad=2.08p pd=8.52u as=2.08p ps=8.52u w=8u l=0.28u
X228 VSS.t185 CLKN_HB.t9 a_2700_41600.t0 VSS.t184 nfet_03v3 ad=2.08p pd=8.52u as=3.52p ps=16.88u w=8u l=0.28u
X229 a_14860_41600.t31 a_6924_41600.t20 VSS.t311 VSS.t310 nfet_03v3 ad=2.08p pd=8.52u as=2.08p ps=8.52u w=8u l=0.28u
X230 VSS.t27 a_14860_41600.t57 O_SENSE.t10 VSS.t26 nfet_03v3 ad=2.08p pd=8.52u as=2.08p ps=8.52u w=8u l=0.28u
X231 E_CAPTURE_CLKB.t13 a_2700_6400.t18 VDD.t157 VDD.t156 pfet_03v3 ad=2.08p pd=8.52u as=2.08p ps=8.52u w=8u l=0.28u
X232 VDD.t259 CLKN_H.t5 a_4812_41600.t6 VDD.t258 pfet_03v3 ad=2.08p pd=8.52u as=2.08p ps=8.52u w=8u l=0.28u
X233 a_14860_41600.t29 a_6924_41600.t34 VDD.t307 VDD.t306 pfet_03v3 ad=2.08p pd=8.52u as=2.08p ps=8.52u w=8u l=0.28u
X234 VSS.t183 CLKN_HB.t5 a_6924_41600.t0 VSS.t182 nfet_03v3 ad=2.08p pd=8.52u as=3.52p ps=16.88u w=8u l=0.28u
X235 VDD.t147 a_6924_6400.t37 a_14860_6400.t21 VDD.t146 pfet_03v3 ad=2.08p pd=8.52u as=2.08p ps=8.52u w=8u l=0.28u
X236 VDD.t207 CLKN_HB.t13 a_6924_41600.t8 VDD.t206 pfet_03v3 ad=2.08p pd=8.52u as=2.08p ps=8.52u w=8u l=0.28u
X237 VSS.t101 a_6924_41600.t17 a_14860_41600.t6 VSS.t100 nfet_03v3 ad=2.08p pd=8.52u as=2.08p ps=8.52u w=8u l=0.28u
X238 VDD.t189 CLKP_HB.t13 a_6924_6400.t8 VDD.t188 pfet_03v3 ad=2.08p pd=8.52u as=2.08p ps=8.52u w=8u l=0.28u
X239 VDD.t93 a_6924_6400.t35 a_14860_6400.t9 VDD.t92 pfet_03v3 ad=2.08p pd=8.52u as=2.08p ps=8.52u w=8u l=0.28u
X240 E_SENSE.t46 a_14860_6400.t64 VDD.t293 VDD.t292 pfet_03v3 ad=3.52p pd=16.88u as=2.08p ps=8.52u w=8u l=0.28u
X241 VDD.t87 a_6924_41600.t31 a_14860_41600.t4 VDD.t86 pfet_03v3 ad=2.08p pd=8.52u as=2.08p ps=8.52u w=8u l=0.28u
X242 VSS.t25 a_14860_41600.t63 O_SENSE.t9 VSS.t24 nfet_03v3 ad=2.08p pd=8.52u as=3.52p ps=16.88u w=8u l=0.28u
X243 E_CAPTURE_CLK.t15 a_4812_6400.t14 VSS.t261 VSS.t260 nfet_03v3 ad=2.08p pd=8.52u as=2.08p ps=8.52u w=8u l=0.28u
X244 VDD.t23 a_2700_41600.t23 O_CAPTURE_CLKB.t1 VDD.t22 pfet_03v3 ad=2.08p pd=8.52u as=3.52p ps=16.88u w=8u l=0.28u
X245 VDD.t33 a_4812_6400.t23 E_CAPTURE_CLK.t2 VDD.t32 pfet_03v3 ad=2.08p pd=8.52u as=3.52p ps=16.88u w=8u l=0.28u
X246 a_6924_41600.t11 CLKN_HB.t10 VDD.t213 VDD.t212 pfet_03v3 ad=3.52p pd=16.88u as=2.08p ps=8.52u w=8u l=0.28u
X247 VSS.t33 a_14860_41600.t37 O_SENSE.t13 VSS.t32 nfet_03v3 ad=2.08p pd=8.52u as=2.08p ps=8.52u w=8u l=0.28u
X248 O_CAPTURE_CLKB.t14 a_2700_41600.t14 VSS.t127 VSS.t126 nfet_03v3 ad=2.08p pd=8.52u as=2.08p ps=8.52u w=8u l=0.28u
X249 E_SENSE.t59 a_14860_6400.t52 VSS.t297 VSS.t296 nfet_03v3 ad=2.08p pd=8.52u as=2.08p ps=8.52u w=8u l=0.28u
X250 E_SENSE.t26 a_14860_6400.t58 VSS.t237 VSS.t236 nfet_03v3 ad=2.08p pd=8.52u as=2.08p ps=8.52u w=8u l=0.28u
X251 VDD.t71 a_14860_41600.t67 O_SENSE.t33 VDD.t70 pfet_03v3 ad=2.08p pd=8.52u as=2.08p ps=8.52u w=8u l=0.28u
X252 VDD.t249 a_14860_6400.t85 E_SENSE.t23 VDD.t248 pfet_03v3 ad=2.08p pd=8.52u as=2.08p ps=8.52u w=8u l=0.28u
X253 E_SENSE.t49 a_14860_6400.t50 VSS.t287 VSS.t286 nfet_03v3 ad=2.08p pd=8.52u as=2.08p ps=8.52u w=8u l=0.28u
X254 VSS.t307 a_2700_6400.t15 E_CAPTURE_CLKB.t15 VSS.t306 nfet_03v3 ad=2.08p pd=8.52u as=3.52p ps=16.88u w=8u l=0.28u
X255 O_CAPTURE_CLKB.t4 a_2700_41600.t20 VDD.t41 VDD.t40 pfet_03v3 ad=2.08p pd=8.52u as=2.08p ps=8.52u w=8u l=0.28u
X256 VSS.t11 a_6924_41600.t23 a_14860_41600.t0 VSS.t10 nfet_03v3 ad=2.08p pd=8.52u as=2.08p ps=8.52u w=8u l=0.28u
X257 O_SENSE.t21 a_14860_41600.t34 VSS.t51 VSS.t50 nfet_03v3 ad=2.08p pd=8.52u as=2.08p ps=8.52u w=8u l=0.28u
X258 O_SENSE.t27 a_14860_41600.t56 VSS.t83 VSS.t82 nfet_03v3 ad=2.08p pd=8.52u as=2.08p ps=8.52u w=8u l=0.28u
X259 a_14860_6400.t24 a_6924_6400.t28 VDD.t153 VDD.t152 pfet_03v3 ad=3.52p pd=16.88u as=2.08p ps=8.52u w=8u l=0.28u
X260 O_SENSE.t3 a_14860_41600.t64 VDD.t7 VDD.t6 pfet_03v3 ad=3.52p pd=16.88u as=2.08p ps=8.52u w=8u l=0.28u
X261 VSS.t243 CLKN_H.t3 a_4812_41600.t0 VSS.t242 nfet_03v3 ad=2.08p pd=8.52u as=3.52p ps=16.88u w=8u l=0.28u
X262 E_CAPTURE_CLK.t0 a_4812_6400.t18 VDD.t29 VDD.t28 pfet_03v3 ad=2.08p pd=8.52u as=2.08p ps=8.52u w=8u l=0.28u
X263 VSS.t239 a_14860_6400.t59 E_SENSE.t27 VSS.t238 nfet_03v3 ad=2.08p pd=8.52u as=2.08p ps=8.52u w=8u l=0.28u
X264 O_SENSE.t0 a_14860_41600.t86 VDD.t1 VDD.t0 pfet_03v3 ad=2.08p pd=8.52u as=2.08p ps=8.52u w=8u l=0.28u
X265 VSS.t85 a_14860_41600.t43 O_SENSE.t28 VSS.t84 nfet_03v3 ad=2.08p pd=8.52u as=2.08p ps=8.52u w=8u l=0.28u
X266 E_SENSE.t24 a_14860_6400.t86 VDD.t251 VDD.t250 pfet_03v3 ad=2.08p pd=8.52u as=2.08p ps=8.52u w=8u l=0.28u
X267 E_SENSE.t42 a_14860_6400.t92 VDD.t287 VDD.t286 pfet_03v3 ad=2.08p pd=8.52u as=2.08p ps=8.52u w=8u l=0.28u
X268 VSS.t273 a_14860_6400.t45 E_SENSE.t37 VSS.t272 nfet_03v3 ad=2.08p pd=8.52u as=2.08p ps=8.52u w=8u l=0.28u
X269 O_CAPTURE_CLK.t15 a_4812_41600.t10 VSS.t125 VSS.t124 nfet_03v3 ad=2.08p pd=8.52u as=2.08p ps=8.52u w=8u l=0.28u
X270 VDD.t173 a_14860_41600.t83 O_SENSE.t55 VDD.t172 pfet_03v3 ad=2.08p pd=8.52u as=2.08p ps=8.52u w=8u l=0.28u
X271 O_SENSE.t5 a_14860_41600.t40 VSS.t7 VSS.t6 nfet_03v3 ad=2.08p pd=8.52u as=2.08p ps=8.52u w=8u l=0.28u
X272 VDD.t129 a_4812_6400.t19 E_CAPTURE_CLK.t6 VDD.t128 pfet_03v3 ad=2.08p pd=8.52u as=2.08p ps=8.52u w=8u l=0.28u
X273 VSS.t229 a_14860_6400.t43 E_SENSE.t21 VSS.t228 nfet_03v3 ad=2.08p pd=8.52u as=2.08p ps=8.52u w=8u l=0.28u
X274 E_CAPTURE_CLK.t13 a_4812_6400.t8 VSS.t233 VSS.t232 nfet_03v3 ad=3.52p pd=16.88u as=2.08p ps=8.52u w=8u l=0.28u
X275 O_SENSE.t37 a_14860_41600.t70 VDD.t99 VDD.t98 pfet_03v3 ad=2.08p pd=8.52u as=2.08p ps=8.52u w=8u l=0.28u
X276 a_14860_41600.t18 a_6924_41600.t42 VDD.t161 VDD.t160 pfet_03v3 ad=2.08p pd=8.52u as=2.08p ps=8.52u w=8u l=0.28u
X277 VDD.t35 a_4812_6400.t17 E_CAPTURE_CLK.t3 VDD.t34 pfet_03v3 ad=2.08p pd=8.52u as=2.08p ps=8.52u w=8u l=0.28u
X278 VDD.t273 a_14860_6400.t93 E_SENSE.t28 VDD.t272 pfet_03v3 ad=2.08p pd=8.52u as=2.08p ps=8.52u w=8u l=0.28u
X279 E_SENSE.t38 a_14860_6400.t46 VSS.t275 VSS.t274 nfet_03v3 ad=2.08p pd=8.52u as=2.08p ps=8.52u w=8u l=0.28u
X280 VDD.t107 a_6924_41600.t29 a_14860_41600.t11 VDD.t106 pfet_03v3 ad=2.08p pd=8.52u as=2.08p ps=8.52u w=8u l=0.28u
X281 E_CAPTURE_CLKB.t11 a_2700_6400.t20 VDD.t139 VDD.t138 pfet_03v3 ad=2.08p pd=8.52u as=2.08p ps=8.52u w=8u l=0.28u
X282 E_SENSE.t22 a_14860_6400.t44 VSS.t231 VSS.t230 nfet_03v3 ad=2.08p pd=8.52u as=2.08p ps=8.52u w=8u l=0.28u
X283 VDD.t297 a_14860_6400.t79 E_SENSE.t54 VDD.t296 pfet_03v3 ad=2.08p pd=8.52u as=2.08p ps=8.52u w=8u l=0.28u
X284 a_14860_41600.t21 a_6924_41600.t12 VSS.t203 VSS.t202 nfet_03v3 ad=3.52p pd=16.88u as=2.08p ps=8.52u w=8u l=0.28u
X285 a_2700_6400.t5 CLKP_HB.t18 VDD.t175 VDD.t174 pfet_03v3 ad=2.08p pd=8.52u as=2.08p ps=8.52u w=8u l=0.28u
X286 VSS.t257 a_6924_6400.t27 a_14860_6400.t29 VSS.t256 nfet_03v3 ad=2.08p pd=8.52u as=3.52p ps=16.88u w=8u l=0.28u
X287 VDD.t119 a_2700_41600.t17 O_CAPTURE_CLKB.t13 VDD.t118 pfet_03v3 ad=2.08p pd=8.52u as=2.08p ps=8.52u w=8u l=0.28u
X288 a_2700_6400.t7 CLKP_HB.t16 VDD.t177 VDD.t176 pfet_03v3 ad=3.52p pd=16.88u as=2.08p ps=8.52u w=8u l=0.28u
X289 E_SENSE.t63 a_14860_6400.t38 VSS.t305 VSS.t304 nfet_03v3 ad=2.08p pd=8.52u as=2.08p ps=8.52u w=8u l=0.28u
X290 VSS.t143 a_6924_6400.t25 a_14860_6400.t19 VSS.t142 nfet_03v3 ad=2.08p pd=8.52u as=2.08p ps=8.52u w=8u l=0.28u
X291 O_SENSE.t63 a_14860_41600.t58 VSS.t241 VSS.t240 nfet_03v3 ad=2.08p pd=8.52u as=2.08p ps=8.52u w=8u l=0.28u
X292 a_4812_41600.t5 CLKN_H.t6 VDD.t257 VDD.t256 pfet_03v3 ad=2.08p pd=8.52u as=2.08p ps=8.52u w=8u l=0.28u
X293 VDD.t37 a_4812_41600.t21 O_CAPTURE_CLK.t3 VDD.t36 pfet_03v3 ad=2.08p pd=8.52u as=2.08p ps=8.52u w=8u l=0.28u
X294 a_4812_6400.t7 CLKP_H.t4 VDD.t81 VDD.t80 pfet_03v3 ad=3.52p pd=16.88u as=2.08p ps=8.52u w=8u l=0.28u
X295 VSS.t249 CLKN_H.t1 a_4812_41600.t2 VSS.t248 nfet_03v3 ad=2.08p pd=8.52u as=2.08p ps=8.52u w=8u l=0.28u
X296 VDD.t201 CLKN_HB.t17 a_2700_41600.t6 VDD.t200 pfet_03v3 ad=2.08p pd=8.52u as=2.08p ps=8.52u w=8u l=0.28u
X297 a_6924_41600.t7 CLKN_HB.t14 VDD.t205 VDD.t204 pfet_03v3 ad=2.08p pd=8.52u as=2.08p ps=8.52u w=8u l=0.28u
X298 a_14860_41600.t7 a_6924_41600.t18 VSS.t103 VSS.t102 nfet_03v3 ad=2.08p pd=8.52u as=2.08p ps=8.52u w=8u l=0.28u
X299 VDD.t181 CLKP_HB.t17 a_2700_6400.t6 VDD.t180 pfet_03v3 ad=2.08p pd=8.52u as=2.08p ps=8.52u w=8u l=0.28u
X300 VSS.t219 a_14860_6400.t39 E_SENSE.t15 VSS.t218 nfet_03v3 ad=2.08p pd=8.52u as=2.08p ps=8.52u w=8u l=0.28u
X301 a_14860_6400.t28 a_6924_6400.t26 VSS.t255 VSS.t254 nfet_03v3 ad=2.08p pd=8.52u as=2.08p ps=8.52u w=8u l=0.28u
X302 VSS.t303 a_14860_6400.t37 E_SENSE.t62 VSS.t302 nfet_03v3 ad=2.08p pd=8.52u as=2.08p ps=8.52u w=8u l=0.28u
X303 E_SENSE.t19 a_14860_6400.t72 VDD.t247 VDD.t246 pfet_03v3 ad=2.08p pd=8.52u as=2.08p ps=8.52u w=8u l=0.28u
X304 VSS.t193 CLKN_HB.t3 a_6924_41600.t2 VSS.t192 nfet_03v3 ad=2.08p pd=8.52u as=2.08p ps=8.52u w=8u l=0.28u
X305 VDD.t79 CLKP_H.t7 a_4812_6400.t4 VDD.t78 pfet_03v3 ad=2.08p pd=8.52u as=3.52p ps=16.88u w=8u l=0.28u
X306 VDD.t85 CLKP_H.t5 a_4812_6400.t6 VDD.t84 pfet_03v3 ad=2.08p pd=8.52u as=2.08p ps=8.52u w=8u l=0.28u
X307 VDD.t209 CLKN_HB.t11 a_6924_41600.t10 VDD.t208 pfet_03v3 ad=2.08p pd=8.52u as=2.08p ps=8.52u w=8u l=0.28u
X308 VDD.t217 a_14860_41600.t81 O_SENSE.t58 VDD.t216 pfet_03v3 ad=2.08p pd=8.52u as=2.08p ps=8.52u w=8u l=0.28u
X309 VSS.t263 a_6924_41600.t15 a_14860_41600.t26 VSS.t262 nfet_03v3 ad=2.08p pd=8.52u as=2.08p ps=8.52u w=8u l=0.28u
X310 a_14860_6400.t22 a_6924_6400.t18 VSS.t147 VSS.t146 nfet_03v3 ad=2.08p pd=8.52u as=2.08p ps=8.52u w=8u l=0.28u
X311 a_6924_6400.t3 CLKP_HB.t2 VSS.t171 VSS.t170 nfet_03v3 ad=2.08p pd=8.52u as=2.08p ps=8.52u w=8u l=0.28u
R0 E_SENSE E_SENSE.n62 11.7381
R1 E_SENSE.n62 E_SENSE.n30 6.5392
R2 E_SENSE.n32 E_SENSE.t40 5.7796
R3 E_SENSE.n1 E_SENSE.t46 5.73764
R4 E_SENSE.n61 E_SENSE.t45 5.59012
R5 E_SENSE.n30 E_SENSE.t53 5.54817
R6 E_SENSE.n32 E_SENSE.n31 5.38537
R7 E_SENSE.n34 E_SENSE.n33 5.38537
R8 E_SENSE.n36 E_SENSE.n35 5.38537
R9 E_SENSE.n38 E_SENSE.n37 5.38537
R10 E_SENSE.n40 E_SENSE.n39 5.38537
R11 E_SENSE.n42 E_SENSE.n41 5.38537
R12 E_SENSE.n44 E_SENSE.n43 5.38537
R13 E_SENSE.n46 E_SENSE.n45 5.38537
R14 E_SENSE.n48 E_SENSE.n47 5.38537
R15 E_SENSE.n50 E_SENSE.n49 5.38537
R16 E_SENSE.n52 E_SENSE.n51 5.38537
R17 E_SENSE.n54 E_SENSE.n53 5.38537
R18 E_SENSE.n56 E_SENSE.n55 5.38537
R19 E_SENSE.n58 E_SENSE.n57 5.38537
R20 E_SENSE.n60 E_SENSE.n59 5.38537
R21 E_SENSE.n1 E_SENSE.n0 5.32067
R22 E_SENSE.n3 E_SENSE.n2 5.32067
R23 E_SENSE.n5 E_SENSE.n4 5.32067
R24 E_SENSE.n7 E_SENSE.n6 5.32067
R25 E_SENSE.n9 E_SENSE.n8 5.32067
R26 E_SENSE.n11 E_SENSE.n10 5.32067
R27 E_SENSE.n13 E_SENSE.n12 5.32067
R28 E_SENSE.n15 E_SENSE.n14 5.32067
R29 E_SENSE.n17 E_SENSE.n16 5.32067
R30 E_SENSE.n19 E_SENSE.n18 5.32067
R31 E_SENSE.n21 E_SENSE.n20 5.32067
R32 E_SENSE.n23 E_SENSE.n22 5.32067
R33 E_SENSE.n25 E_SENSE.n24 5.32067
R34 E_SENSE.n27 E_SENSE.n26 5.32067
R35 E_SENSE.n29 E_SENSE.n28 5.32067
R36 E_SENSE.n62 E_SENSE.n61 4.61063
R37 E_SENSE.n0 E_SENSE.t57 0.228
R38 E_SENSE.n0 E_SENSE.t56 0.228
R39 E_SENSE.n2 E_SENSE.t7 0.228
R40 E_SENSE.n2 E_SENSE.t6 0.228
R41 E_SENSE.n4 E_SENSE.t11 0.228
R42 E_SENSE.n4 E_SENSE.t10 0.228
R43 E_SENSE.n6 E_SENSE.t19 0.228
R44 E_SENSE.n6 E_SENSE.t18 0.228
R45 E_SENSE.n8 E_SENSE.t3 0.228
R46 E_SENSE.n8 E_SENSE.t2 0.228
R47 E_SENSE.n10 E_SENSE.t33 0.228
R48 E_SENSE.n10 E_SENSE.t32 0.228
R49 E_SENSE.n12 E_SENSE.t44 0.228
R50 E_SENSE.n12 E_SENSE.t43 0.228
R51 E_SENSE.n14 E_SENSE.t55 0.228
R52 E_SENSE.n14 E_SENSE.t54 0.228
R53 E_SENSE.n16 E_SENSE.t5 0.228
R54 E_SENSE.n16 E_SENSE.t4 0.228
R55 E_SENSE.n18 E_SENSE.t9 0.228
R56 E_SENSE.n18 E_SENSE.t8 0.228
R57 E_SENSE.n20 E_SENSE.t24 0.228
R58 E_SENSE.n20 E_SENSE.t23 0.228
R59 E_SENSE.n22 E_SENSE.t1 0.228
R60 E_SENSE.n22 E_SENSE.t0 0.228
R61 E_SENSE.n24 E_SENSE.t31 0.228
R62 E_SENSE.n24 E_SENSE.t30 0.228
R63 E_SENSE.n26 E_SENSE.t42 0.228
R64 E_SENSE.n26 E_SENSE.t41 0.228
R65 E_SENSE.n28 E_SENSE.t29 0.228
R66 E_SENSE.n28 E_SENSE.t28 0.228
R67 E_SENSE.n31 E_SENSE.t51 0.20525
R68 E_SENSE.n31 E_SENSE.t50 0.20525
R69 E_SENSE.n33 E_SENSE.t61 0.20525
R70 E_SENSE.n33 E_SENSE.t52 0.20525
R71 E_SENSE.n35 E_SENSE.t63 0.20525
R72 E_SENSE.n35 E_SENSE.t62 0.20525
R73 E_SENSE.n37 E_SENSE.t16 0.20525
R74 E_SENSE.n37 E_SENSE.t15 0.20525
R75 E_SENSE.n39 E_SENSE.t20 0.20525
R76 E_SENSE.n39 E_SENSE.t17 0.20525
R77 E_SENSE.n41 E_SENSE.t22 0.20525
R78 E_SENSE.n41 E_SENSE.t21 0.20525
R79 E_SENSE.n43 E_SENSE.t38 0.20525
R80 E_SENSE.n43 E_SENSE.t37 0.20525
R81 E_SENSE.n45 E_SENSE.t47 0.20525
R82 E_SENSE.n45 E_SENSE.t39 0.20525
R83 E_SENSE.n47 E_SENSE.t49 0.20525
R84 E_SENSE.n47 E_SENSE.t48 0.20525
R85 E_SENSE.n49 E_SENSE.t59 0.20525
R86 E_SENSE.n49 E_SENSE.t58 0.20525
R87 E_SENSE.n51 E_SENSE.t12 0.20525
R88 E_SENSE.n51 E_SENSE.t60 0.20525
R89 E_SENSE.n53 E_SENSE.t14 0.20525
R90 E_SENSE.n53 E_SENSE.t13 0.20525
R91 E_SENSE.n55 E_SENSE.t26 0.20525
R92 E_SENSE.n55 E_SENSE.t25 0.20525
R93 E_SENSE.n57 E_SENSE.t34 0.20525
R94 E_SENSE.n57 E_SENSE.t27 0.20525
R95 E_SENSE.n59 E_SENSE.t36 0.20525
R96 E_SENSE.n59 E_SENSE.t35 0.20525
R97 E_SENSE.n61 E_SENSE.n60 0.189974
R98 E_SENSE.n60 E_SENSE.n58 0.189974
R99 E_SENSE.n58 E_SENSE.n56 0.189974
R100 E_SENSE.n56 E_SENSE.n54 0.189974
R101 E_SENSE.n54 E_SENSE.n52 0.189974
R102 E_SENSE.n52 E_SENSE.n50 0.189974
R103 E_SENSE.n50 E_SENSE.n48 0.189974
R104 E_SENSE.n48 E_SENSE.n46 0.189974
R105 E_SENSE.n46 E_SENSE.n44 0.189974
R106 E_SENSE.n44 E_SENSE.n42 0.189974
R107 E_SENSE.n42 E_SENSE.n40 0.189974
R108 E_SENSE.n40 E_SENSE.n38 0.189974
R109 E_SENSE.n38 E_SENSE.n36 0.189974
R110 E_SENSE.n36 E_SENSE.n34 0.189974
R111 E_SENSE.n34 E_SENSE.n32 0.189974
R112 E_SENSE.n30 E_SENSE.n29 0.189974
R113 E_SENSE.n29 E_SENSE.n27 0.189974
R114 E_SENSE.n27 E_SENSE.n25 0.189974
R115 E_SENSE.n25 E_SENSE.n23 0.189974
R116 E_SENSE.n23 E_SENSE.n21 0.189974
R117 E_SENSE.n21 E_SENSE.n19 0.189974
R118 E_SENSE.n19 E_SENSE.n17 0.189974
R119 E_SENSE.n17 E_SENSE.n15 0.189974
R120 E_SENSE.n15 E_SENSE.n13 0.189974
R121 E_SENSE.n13 E_SENSE.n11 0.189974
R122 E_SENSE.n11 E_SENSE.n9 0.189974
R123 E_SENSE.n9 E_SENSE.n7 0.189974
R124 E_SENSE.n7 E_SENSE.n5 0.189974
R125 E_SENSE.n5 E_SENSE.n3 0.189974
R126 E_SENSE.n3 E_SENSE.n1 0.189974
R127 E_CAPTURE_CLK E_CAPTURE_CLK.n14 7.98157
R128 E_CAPTURE_CLK.n14 E_CAPTURE_CLK.n6 6.5392
R129 E_CAPTURE_CLK.n8 E_CAPTURE_CLK.t13 5.7796
R130 E_CAPTURE_CLK.n1 E_CAPTURE_CLK.t4 5.73764
R131 E_CAPTURE_CLK.n13 E_CAPTURE_CLK.t11 5.59012
R132 E_CAPTURE_CLK.n6 E_CAPTURE_CLK.t2 5.54817
R133 E_CAPTURE_CLK.n8 E_CAPTURE_CLK.n7 5.38537
R134 E_CAPTURE_CLK.n10 E_CAPTURE_CLK.n9 5.38537
R135 E_CAPTURE_CLK.n12 E_CAPTURE_CLK.n11 5.38537
R136 E_CAPTURE_CLK.n1 E_CAPTURE_CLK.n0 5.32067
R137 E_CAPTURE_CLK.n3 E_CAPTURE_CLK.n2 5.32067
R138 E_CAPTURE_CLK.n5 E_CAPTURE_CLK.n4 5.32067
R139 E_CAPTURE_CLK.n14 E_CAPTURE_CLK.n13 4.61063
R140 E_CAPTURE_CLK.n0 E_CAPTURE_CLK.t0 0.228
R141 E_CAPTURE_CLK.n0 E_CAPTURE_CLK.t3 0.228
R142 E_CAPTURE_CLK.n2 E_CAPTURE_CLK.t5 0.228
R143 E_CAPTURE_CLK.n2 E_CAPTURE_CLK.t6 0.228
R144 E_CAPTURE_CLK.n4 E_CAPTURE_CLK.t1 0.228
R145 E_CAPTURE_CLK.n4 E_CAPTURE_CLK.t7 0.228
R146 E_CAPTURE_CLK.n7 E_CAPTURE_CLK.t10 0.20525
R147 E_CAPTURE_CLK.n7 E_CAPTURE_CLK.t14 0.20525
R148 E_CAPTURE_CLK.n9 E_CAPTURE_CLK.t8 0.20525
R149 E_CAPTURE_CLK.n9 E_CAPTURE_CLK.t9 0.20525
R150 E_CAPTURE_CLK.n11 E_CAPTURE_CLK.t15 0.20525
R151 E_CAPTURE_CLK.n11 E_CAPTURE_CLK.t12 0.20525
R152 E_CAPTURE_CLK.n13 E_CAPTURE_CLK.n12 0.189974
R153 E_CAPTURE_CLK.n12 E_CAPTURE_CLK.n10 0.189974
R154 E_CAPTURE_CLK.n10 E_CAPTURE_CLK.n8 0.189974
R155 E_CAPTURE_CLK.n6 E_CAPTURE_CLK.n5 0.189974
R156 E_CAPTURE_CLK.n5 E_CAPTURE_CLK.n3 0.189974
R157 E_CAPTURE_CLK.n3 E_CAPTURE_CLK.n1 0.189974
R158 E_CAPTURE_CLKB E_CAPTURE_CLKB.n14 6.63157
R159 E_CAPTURE_CLKB.n14 E_CAPTURE_CLKB.n6 6.5392
R160 E_CAPTURE_CLKB.n8 E_CAPTURE_CLKB.t5 5.7796
R161 E_CAPTURE_CLKB.n1 E_CAPTURE_CLKB.t1 5.73764
R162 E_CAPTURE_CLKB.n13 E_CAPTURE_CLKB.t15 5.59012
R163 E_CAPTURE_CLKB.n6 E_CAPTURE_CLKB.t3 5.54817
R164 E_CAPTURE_CLKB.n8 E_CAPTURE_CLKB.n7 5.38537
R165 E_CAPTURE_CLKB.n10 E_CAPTURE_CLKB.n9 5.38537
R166 E_CAPTURE_CLKB.n12 E_CAPTURE_CLKB.n11 5.38537
R167 E_CAPTURE_CLKB.n1 E_CAPTURE_CLKB.n0 5.32067
R168 E_CAPTURE_CLKB.n3 E_CAPTURE_CLKB.n2 5.32067
R169 E_CAPTURE_CLKB.n5 E_CAPTURE_CLKB.n4 5.32067
R170 E_CAPTURE_CLKB.n14 E_CAPTURE_CLKB.n13 4.61063
R171 E_CAPTURE_CLKB.n0 E_CAPTURE_CLKB.t13 0.228
R172 E_CAPTURE_CLKB.n0 E_CAPTURE_CLKB.t14 0.228
R173 E_CAPTURE_CLKB.n2 E_CAPTURE_CLKB.t11 0.228
R174 E_CAPTURE_CLKB.n2 E_CAPTURE_CLKB.t0 0.228
R175 E_CAPTURE_CLKB.n4 E_CAPTURE_CLKB.t6 0.228
R176 E_CAPTURE_CLKB.n4 E_CAPTURE_CLKB.t2 0.228
R177 E_CAPTURE_CLKB.n7 E_CAPTURE_CLKB.t12 0.20525
R178 E_CAPTURE_CLKB.n7 E_CAPTURE_CLKB.t8 0.20525
R179 E_CAPTURE_CLKB.n9 E_CAPTURE_CLKB.t10 0.20525
R180 E_CAPTURE_CLKB.n9 E_CAPTURE_CLKB.t7 0.20525
R181 E_CAPTURE_CLKB.n11 E_CAPTURE_CLKB.t9 0.20525
R182 E_CAPTURE_CLKB.n11 E_CAPTURE_CLKB.t4 0.20525
R183 E_CAPTURE_CLKB.n13 E_CAPTURE_CLKB.n12 0.189974
R184 E_CAPTURE_CLKB.n12 E_CAPTURE_CLKB.n10 0.189974
R185 E_CAPTURE_CLKB.n10 E_CAPTURE_CLKB.n8 0.189974
R186 E_CAPTURE_CLKB.n6 E_CAPTURE_CLKB.n5 0.189974
R187 E_CAPTURE_CLKB.n5 E_CAPTURE_CLKB.n3 0.189974
R188 E_CAPTURE_CLKB.n3 E_CAPTURE_CLKB.n1 0.189974
R189 CLKP_H.n8 CLKP_H.t3 113.632
R190 CLKP_H.n5 CLKP_H.t0 113.632
R191 CLKP_H.n0 CLKP_H.t4 113.632
R192 CLKP_H.n3 CLKP_H.t7 113.632
R193 CLKP_H.n6 CLKP_H.t1 109.174
R194 CLKP_H.n7 CLKP_H.t2 109.174
R195 CLKP_H.n1 CLKP_H.t5 109.174
R196 CLKP_H.n2 CLKP_H.t6 109.174
R197 CLKP_H CLKP_H.n10 15.3874
R198 CLKP_H.n7 CLKP_H.n6 11.6805
R199 CLKP_H.n2 CLKP_H.n1 11.6805
R200 CLKP_H.n10 CLKP_H.n4 10.9291
R201 CLKP_H.n10 CLKP_H.n9 9.0005
R202 CLKP_H.n9 CLKP_H.n5 7.10487
R203 CLKP_H.n9 CLKP_H.n8 7.10487
R204 CLKP_H.n4 CLKP_H.n0 7.10487
R205 CLKP_H.n4 CLKP_H.n3 7.10487
R206 CLKP_H.n6 CLKP_H.n5 4.42851
R207 CLKP_H.n8 CLKP_H.n7 4.42851
R208 CLKP_H.n1 CLKP_H.n0 4.42851
R209 CLKP_H.n3 CLKP_H.n2 4.42851
R210 CLKP_HB.n10 CLKP_HB.t5 113.632
R211 CLKP_HB.n12 CLKP_HB.t0 113.632
R212 CLKP_HB.n1 CLKP_HB.t15 113.632
R213 CLKP_HB.n3 CLKP_HB.t10 113.632
R214 CLKP_HB.n27 CLKP_HB.t9 113.632
R215 CLKP_HB.n24 CLKP_HB.t6 113.632
R216 CLKP_HB.n19 CLKP_HB.t16 113.632
R217 CLKP_HB.n22 CLKP_HB.t19 113.632
R218 CLKP_HB.n14 CLKP_HB.t2 109.174
R219 CLKP_HB.n15 CLKP_HB.t3 109.174
R220 CLKP_HB.n11 CLKP_HB.t4 109.174
R221 CLKP_HB.n13 CLKP_HB.t1 109.174
R222 CLKP_HB.n5 CLKP_HB.t12 109.174
R223 CLKP_HB.n6 CLKP_HB.t13 109.174
R224 CLKP_HB.n2 CLKP_HB.t14 109.174
R225 CLKP_HB.n4 CLKP_HB.t11 109.174
R226 CLKP_HB.n25 CLKP_HB.t7 109.174
R227 CLKP_HB.n26 CLKP_HB.t8 109.174
R228 CLKP_HB.n20 CLKP_HB.t17 109.174
R229 CLKP_HB.n21 CLKP_HB.t18 109.174
R230 CLKP_HB.n14 CLKP_HB.n9 18.4942
R231 CLKP_HB.n16 CLKP_HB.n15 18.4942
R232 CLKP_HB.n5 CLKP_HB.n0 18.4942
R233 CLKP_HB.n7 CLKP_HB.n6 18.4942
R234 CLKP_HB.n14 CLKP_HB.n13 11.6805
R235 CLKP_HB.n15 CLKP_HB.n14 11.6805
R236 CLKP_HB.n15 CLKP_HB.n11 11.6805
R237 CLKP_HB.n5 CLKP_HB.n4 11.6805
R238 CLKP_HB.n6 CLKP_HB.n5 11.6805
R239 CLKP_HB.n6 CLKP_HB.n2 11.6805
R240 CLKP_HB.n26 CLKP_HB.n25 11.6805
R241 CLKP_HB.n21 CLKP_HB.n20 11.6805
R242 CLKP_HB.n18 CLKP_HB.n8 10.9291
R243 CLKP_HB.n29 CLKP_HB.n23 10.9291
R244 CLKP_HB.n18 CLKP_HB.n17 9.0005
R245 CLKP_HB.n29 CLKP_HB.n28 9.0005
R246 CLKP_HB.n30 CLKP_HB.n18 8.86606
R247 CLKP_HB CLKP_HB.n30 8.25354
R248 CLKP_HB.n12 CLKP_HB.n9 7.17687
R249 CLKP_HB.n16 CLKP_HB.n10 7.17687
R250 CLKP_HB.n3 CLKP_HB.n0 7.17687
R251 CLKP_HB.n7 CLKP_HB.n1 7.17687
R252 CLKP_HB.n28 CLKP_HB.n24 7.10487
R253 CLKP_HB.n28 CLKP_HB.n27 7.10487
R254 CLKP_HB.n23 CLKP_HB.n19 7.10487
R255 CLKP_HB.n23 CLKP_HB.n22 7.10487
R256 CLKP_HB.n30 CLKP_HB.n29 4.59693
R257 CLKP_HB.n11 CLKP_HB.n10 4.42851
R258 CLKP_HB.n13 CLKP_HB.n12 4.42851
R259 CLKP_HB.n2 CLKP_HB.n1 4.42851
R260 CLKP_HB.n4 CLKP_HB.n3 4.42851
R261 CLKP_HB.n25 CLKP_HB.n24 4.42851
R262 CLKP_HB.n27 CLKP_HB.n26 4.42851
R263 CLKP_HB.n20 CLKP_HB.n19 4.42851
R264 CLKP_HB.n22 CLKP_HB.n21 4.42851
R265 CLKP_HB.n17 CLKP_HB.n9 0.0485
R266 CLKP_HB.n17 CLKP_HB.n16 0.0485
R267 CLKP_HB.n8 CLKP_HB.n0 0.0485
R268 CLKP_HB.n8 CLKP_HB.n7 0.0485
R269 O_SENSE O_SENSE.n62 11.7381
R270 O_SENSE.n62 O_SENSE.n30 6.5392
R271 O_SENSE.n32 O_SENSE.t6 5.7796
R272 O_SENSE.n1 O_SENSE.t3 5.73764
R273 O_SENSE.n61 O_SENSE.t9 5.59012
R274 O_SENSE.n30 O_SENSE.t34 5.54817
R275 O_SENSE.n32 O_SENSE.n31 5.38537
R276 O_SENSE.n34 O_SENSE.n33 5.38537
R277 O_SENSE.n36 O_SENSE.n35 5.38537
R278 O_SENSE.n38 O_SENSE.n37 5.38537
R279 O_SENSE.n40 O_SENSE.n39 5.38537
R280 O_SENSE.n42 O_SENSE.n41 5.38537
R281 O_SENSE.n44 O_SENSE.n43 5.38537
R282 O_SENSE.n46 O_SENSE.n45 5.38537
R283 O_SENSE.n48 O_SENSE.n47 5.38537
R284 O_SENSE.n50 O_SENSE.n49 5.38537
R285 O_SENSE.n52 O_SENSE.n51 5.38537
R286 O_SENSE.n54 O_SENSE.n53 5.38537
R287 O_SENSE.n56 O_SENSE.n55 5.38537
R288 O_SENSE.n58 O_SENSE.n57 5.38537
R289 O_SENSE.n60 O_SENSE.n59 5.38537
R290 O_SENSE.n1 O_SENSE.n0 5.32067
R291 O_SENSE.n3 O_SENSE.n2 5.32067
R292 O_SENSE.n5 O_SENSE.n4 5.32067
R293 O_SENSE.n7 O_SENSE.n6 5.32067
R294 O_SENSE.n9 O_SENSE.n8 5.32067
R295 O_SENSE.n11 O_SENSE.n10 5.32067
R296 O_SENSE.n13 O_SENSE.n12 5.32067
R297 O_SENSE.n15 O_SENSE.n14 5.32067
R298 O_SENSE.n17 O_SENSE.n16 5.32067
R299 O_SENSE.n19 O_SENSE.n18 5.32067
R300 O_SENSE.n21 O_SENSE.n20 5.32067
R301 O_SENSE.n23 O_SENSE.n22 5.32067
R302 O_SENSE.n25 O_SENSE.n24 5.32067
R303 O_SENSE.n27 O_SENSE.n26 5.32067
R304 O_SENSE.n29 O_SENSE.n28 5.32067
R305 O_SENSE.n62 O_SENSE.n61 4.61063
R306 O_SENSE.n0 O_SENSE.t42 0.228
R307 O_SENSE.n0 O_SENSE.t17 0.228
R308 O_SENSE.n2 O_SENSE.t45 0.228
R309 O_SENSE.n2 O_SENSE.t33 0.228
R310 O_SENSE.n4 O_SENSE.t37 0.228
R311 O_SENSE.n4 O_SENSE.t41 0.228
R312 O_SENSE.n6 O_SENSE.t40 0.228
R313 O_SENSE.n6 O_SENSE.t44 0.228
R314 O_SENSE.n8 O_SENSE.t8 0.228
R315 O_SENSE.n8 O_SENSE.t24 0.228
R316 O_SENSE.n10 O_SENSE.t16 0.228
R317 O_SENSE.n10 O_SENSE.t2 0.228
R318 O_SENSE.n12 O_SENSE.t7 0.228
R319 O_SENSE.n12 O_SENSE.t23 0.228
R320 O_SENSE.n14 O_SENSE.t15 0.228
R321 O_SENSE.n14 O_SENSE.t1 0.228
R322 O_SENSE.n16 O_SENSE.t36 0.228
R323 O_SENSE.n16 O_SENSE.t58 0.228
R324 O_SENSE.n18 O_SENSE.t35 0.228
R325 O_SENSE.n18 O_SENSE.t55 0.228
R326 O_SENSE.n20 O_SENSE.t0 0.228
R327 O_SENSE.n20 O_SENSE.t22 0.228
R328 O_SENSE.n22 O_SENSE.t54 0.228
R329 O_SENSE.n22 O_SENSE.t62 0.228
R330 O_SENSE.n24 O_SENSE.t32 0.228
R331 O_SENSE.n24 O_SENSE.t61 0.228
R332 O_SENSE.n26 O_SENSE.t52 0.228
R333 O_SENSE.n26 O_SENSE.t51 0.228
R334 O_SENSE.n28 O_SENSE.t38 0.228
R335 O_SENSE.n28 O_SENSE.t53 0.228
R336 O_SENSE.n31 O_SENSE.t21 0.20525
R337 O_SENSE.n31 O_SENSE.t20 0.20525
R338 O_SENSE.n33 O_SENSE.t31 0.20525
R339 O_SENSE.n33 O_SENSE.t30 0.20525
R340 O_SENSE.n35 O_SENSE.t14 0.20525
R341 O_SENSE.n35 O_SENSE.t13 0.20525
R342 O_SENSE.n37 O_SENSE.t5 0.20525
R343 O_SENSE.n37 O_SENSE.t4 0.20525
R344 O_SENSE.n39 O_SENSE.t19 0.20525
R345 O_SENSE.n39 O_SENSE.t18 0.20525
R346 O_SENSE.n41 O_SENSE.t29 0.20525
R347 O_SENSE.n41 O_SENSE.t28 0.20525
R348 O_SENSE.n43 O_SENSE.t12 0.20525
R349 O_SENSE.n43 O_SENSE.t11 0.20525
R350 O_SENSE.n45 O_SENSE.t60 0.20525
R351 O_SENSE.n45 O_SENSE.t59 0.20525
R352 O_SENSE.n47 O_SENSE.t50 0.20525
R353 O_SENSE.n47 O_SENSE.t49 0.20525
R354 O_SENSE.n49 O_SENSE.t48 0.20525
R355 O_SENSE.n49 O_SENSE.t47 0.20525
R356 O_SENSE.n51 O_SENSE.t57 0.20525
R357 O_SENSE.n51 O_SENSE.t56 0.20525
R358 O_SENSE.n53 O_SENSE.t27 0.20525
R359 O_SENSE.n53 O_SENSE.t26 0.20525
R360 O_SENSE.n55 O_SENSE.t63 0.20525
R361 O_SENSE.n55 O_SENSE.t10 0.20525
R362 O_SENSE.n57 O_SENSE.t46 0.20525
R363 O_SENSE.n57 O_SENSE.t43 0.20525
R364 O_SENSE.n59 O_SENSE.t25 0.20525
R365 O_SENSE.n59 O_SENSE.t39 0.20525
R366 O_SENSE.n61 O_SENSE.n60 0.189974
R367 O_SENSE.n60 O_SENSE.n58 0.189974
R368 O_SENSE.n58 O_SENSE.n56 0.189974
R369 O_SENSE.n56 O_SENSE.n54 0.189974
R370 O_SENSE.n54 O_SENSE.n52 0.189974
R371 O_SENSE.n52 O_SENSE.n50 0.189974
R372 O_SENSE.n50 O_SENSE.n48 0.189974
R373 O_SENSE.n48 O_SENSE.n46 0.189974
R374 O_SENSE.n46 O_SENSE.n44 0.189974
R375 O_SENSE.n44 O_SENSE.n42 0.189974
R376 O_SENSE.n42 O_SENSE.n40 0.189974
R377 O_SENSE.n40 O_SENSE.n38 0.189974
R378 O_SENSE.n38 O_SENSE.n36 0.189974
R379 O_SENSE.n36 O_SENSE.n34 0.189974
R380 O_SENSE.n34 O_SENSE.n32 0.189974
R381 O_SENSE.n30 O_SENSE.n29 0.189974
R382 O_SENSE.n29 O_SENSE.n27 0.189974
R383 O_SENSE.n27 O_SENSE.n25 0.189974
R384 O_SENSE.n25 O_SENSE.n23 0.189974
R385 O_SENSE.n23 O_SENSE.n21 0.189974
R386 O_SENSE.n21 O_SENSE.n19 0.189974
R387 O_SENSE.n19 O_SENSE.n17 0.189974
R388 O_SENSE.n17 O_SENSE.n15 0.189974
R389 O_SENSE.n15 O_SENSE.n13 0.189974
R390 O_SENSE.n13 O_SENSE.n11 0.189974
R391 O_SENSE.n11 O_SENSE.n9 0.189974
R392 O_SENSE.n9 O_SENSE.n7 0.189974
R393 O_SENSE.n7 O_SENSE.n5 0.189974
R394 O_SENSE.n5 O_SENSE.n3 0.189974
R395 O_SENSE.n3 O_SENSE.n1 0.189974
R396 O_CAPTURE_CLK O_CAPTURE_CLK.n14 7.98157
R397 O_CAPTURE_CLK.n14 O_CAPTURE_CLK.n6 6.5392
R398 O_CAPTURE_CLK.n8 O_CAPTURE_CLK.t2 5.7796
R399 O_CAPTURE_CLK.n1 O_CAPTURE_CLK.t11 5.73764
R400 O_CAPTURE_CLK.n13 O_CAPTURE_CLK.t10 5.59012
R401 O_CAPTURE_CLK.n6 O_CAPTURE_CLK.t7 5.54817
R402 O_CAPTURE_CLK.n8 O_CAPTURE_CLK.n7 5.38537
R403 O_CAPTURE_CLK.n10 O_CAPTURE_CLK.n9 5.38537
R404 O_CAPTURE_CLK.n12 O_CAPTURE_CLK.n11 5.38537
R405 O_CAPTURE_CLK.n1 O_CAPTURE_CLK.n0 5.32067
R406 O_CAPTURE_CLK.n3 O_CAPTURE_CLK.n2 5.32067
R407 O_CAPTURE_CLK.n5 O_CAPTURE_CLK.n4 5.32067
R408 O_CAPTURE_CLK.n14 O_CAPTURE_CLK.n13 4.61063
R409 O_CAPTURE_CLK.n0 O_CAPTURE_CLK.t1 0.228
R410 O_CAPTURE_CLK.n0 O_CAPTURE_CLK.t0 0.228
R411 O_CAPTURE_CLK.n2 O_CAPTURE_CLK.t13 0.228
R412 O_CAPTURE_CLK.n2 O_CAPTURE_CLK.t12 0.228
R413 O_CAPTURE_CLK.n4 O_CAPTURE_CLK.t4 0.228
R414 O_CAPTURE_CLK.n4 O_CAPTURE_CLK.t3 0.228
R415 O_CAPTURE_CLK.n7 O_CAPTURE_CLK.t15 0.20525
R416 O_CAPTURE_CLK.n7 O_CAPTURE_CLK.t14 0.20525
R417 O_CAPTURE_CLK.n9 O_CAPTURE_CLK.t6 0.20525
R418 O_CAPTURE_CLK.n9 O_CAPTURE_CLK.t5 0.20525
R419 O_CAPTURE_CLK.n11 O_CAPTURE_CLK.t9 0.20525
R420 O_CAPTURE_CLK.n11 O_CAPTURE_CLK.t8 0.20525
R421 O_CAPTURE_CLK.n13 O_CAPTURE_CLK.n12 0.189974
R422 O_CAPTURE_CLK.n12 O_CAPTURE_CLK.n10 0.189974
R423 O_CAPTURE_CLK.n10 O_CAPTURE_CLK.n8 0.189974
R424 O_CAPTURE_CLK.n6 O_CAPTURE_CLK.n5 0.189974
R425 O_CAPTURE_CLK.n5 O_CAPTURE_CLK.n3 0.189974
R426 O_CAPTURE_CLK.n3 O_CAPTURE_CLK.n1 0.189974
R427 O_CAPTURE_CLKB O_CAPTURE_CLKB.n14 6.63157
R428 O_CAPTURE_CLKB.n14 O_CAPTURE_CLKB.n6 6.5392
R429 O_CAPTURE_CLKB.n8 O_CAPTURE_CLKB.t3 5.7796
R430 O_CAPTURE_CLKB.n1 O_CAPTURE_CLKB.t12 5.73764
R431 O_CAPTURE_CLKB.n13 O_CAPTURE_CLKB.t15 5.59012
R432 O_CAPTURE_CLKB.n6 O_CAPTURE_CLKB.t1 5.54817
R433 O_CAPTURE_CLKB.n8 O_CAPTURE_CLKB.n7 5.38537
R434 O_CAPTURE_CLKB.n10 O_CAPTURE_CLKB.n9 5.38537
R435 O_CAPTURE_CLKB.n12 O_CAPTURE_CLKB.n11 5.38537
R436 O_CAPTURE_CLKB.n1 O_CAPTURE_CLKB.n0 5.32067
R437 O_CAPTURE_CLKB.n3 O_CAPTURE_CLKB.n2 5.32067
R438 O_CAPTURE_CLKB.n5 O_CAPTURE_CLKB.n4 5.32067
R439 O_CAPTURE_CLKB.n14 O_CAPTURE_CLKB.n13 4.61063
R440 O_CAPTURE_CLKB.n0 O_CAPTURE_CLKB.t8 0.228
R441 O_CAPTURE_CLKB.n0 O_CAPTURE_CLKB.t13 0.228
R442 O_CAPTURE_CLKB.n2 O_CAPTURE_CLKB.t4 0.228
R443 O_CAPTURE_CLKB.n2 O_CAPTURE_CLKB.t9 0.228
R444 O_CAPTURE_CLKB.n4 O_CAPTURE_CLKB.t0 0.228
R445 O_CAPTURE_CLKB.n4 O_CAPTURE_CLKB.t5 0.228
R446 O_CAPTURE_CLKB.n7 O_CAPTURE_CLKB.t7 0.20525
R447 O_CAPTURE_CLKB.n7 O_CAPTURE_CLKB.t6 0.20525
R448 O_CAPTURE_CLKB.n9 O_CAPTURE_CLKB.t10 0.20525
R449 O_CAPTURE_CLKB.n9 O_CAPTURE_CLKB.t2 0.20525
R450 O_CAPTURE_CLKB.n11 O_CAPTURE_CLKB.t14 0.20525
R451 O_CAPTURE_CLKB.n11 O_CAPTURE_CLKB.t11 0.20525
R452 O_CAPTURE_CLKB.n13 O_CAPTURE_CLKB.n12 0.189974
R453 O_CAPTURE_CLKB.n12 O_CAPTURE_CLKB.n10 0.189974
R454 O_CAPTURE_CLKB.n10 O_CAPTURE_CLKB.n8 0.189974
R455 O_CAPTURE_CLKB.n6 O_CAPTURE_CLKB.n5 0.189974
R456 O_CAPTURE_CLKB.n5 O_CAPTURE_CLKB.n3 0.189974
R457 O_CAPTURE_CLKB.n3 O_CAPTURE_CLKB.n1 0.189974
R458 CLKN_H.n8 CLKN_H.t3 113.632
R459 CLKN_H.n5 CLKN_H.t0 113.632
R460 CLKN_H.n0 CLKN_H.t4 113.632
R461 CLKN_H.n3 CLKN_H.t7 113.632
R462 CLKN_H.n6 CLKN_H.t1 109.174
R463 CLKN_H.n7 CLKN_H.t2 109.174
R464 CLKN_H.n1 CLKN_H.t5 109.174
R465 CLKN_H.n2 CLKN_H.t6 109.174
R466 CLKN_H CLKN_H.n10 15.3874
R467 CLKN_H.n7 CLKN_H.n6 11.6805
R468 CLKN_H.n2 CLKN_H.n1 11.6805
R469 CLKN_H.n10 CLKN_H.n4 10.9291
R470 CLKN_H.n10 CLKN_H.n9 9.0005
R471 CLKN_H.n9 CLKN_H.n5 7.10487
R472 CLKN_H.n9 CLKN_H.n8 7.10487
R473 CLKN_H.n4 CLKN_H.n0 7.10487
R474 CLKN_H.n4 CLKN_H.n3 7.10487
R475 CLKN_H.n6 CLKN_H.n5 4.42851
R476 CLKN_H.n8 CLKN_H.n7 4.42851
R477 CLKN_H.n1 CLKN_H.n0 4.42851
R478 CLKN_H.n3 CLKN_H.n2 4.42851
R479 CLKN_HB.n10 CLKN_HB.t5 113.632
R480 CLKN_HB.n12 CLKN_HB.t0 113.632
R481 CLKN_HB.n1 CLKN_HB.t15 113.632
R482 CLKN_HB.n3 CLKN_HB.t10 113.632
R483 CLKN_HB.n27 CLKN_HB.t9 113.632
R484 CLKN_HB.n24 CLKN_HB.t6 113.632
R485 CLKN_HB.n19 CLKN_HB.t16 113.632
R486 CLKN_HB.n22 CLKN_HB.t19 113.632
R487 CLKN_HB.n14 CLKN_HB.t2 109.174
R488 CLKN_HB.n15 CLKN_HB.t3 109.174
R489 CLKN_HB.n11 CLKN_HB.t4 109.174
R490 CLKN_HB.n13 CLKN_HB.t1 109.174
R491 CLKN_HB.n5 CLKN_HB.t12 109.174
R492 CLKN_HB.n6 CLKN_HB.t13 109.174
R493 CLKN_HB.n2 CLKN_HB.t14 109.174
R494 CLKN_HB.n4 CLKN_HB.t11 109.174
R495 CLKN_HB.n25 CLKN_HB.t7 109.174
R496 CLKN_HB.n26 CLKN_HB.t8 109.174
R497 CLKN_HB.n20 CLKN_HB.t17 109.174
R498 CLKN_HB.n21 CLKN_HB.t18 109.174
R499 CLKN_HB.n14 CLKN_HB.n9 18.4942
R500 CLKN_HB.n16 CLKN_HB.n15 18.4942
R501 CLKN_HB.n5 CLKN_HB.n0 18.4942
R502 CLKN_HB.n7 CLKN_HB.n6 18.4942
R503 CLKN_HB.n14 CLKN_HB.n13 11.6805
R504 CLKN_HB.n15 CLKN_HB.n14 11.6805
R505 CLKN_HB.n15 CLKN_HB.n11 11.6805
R506 CLKN_HB.n5 CLKN_HB.n4 11.6805
R507 CLKN_HB.n6 CLKN_HB.n5 11.6805
R508 CLKN_HB.n6 CLKN_HB.n2 11.6805
R509 CLKN_HB.n26 CLKN_HB.n25 11.6805
R510 CLKN_HB.n21 CLKN_HB.n20 11.6805
R511 CLKN_HB.n18 CLKN_HB.n8 10.9291
R512 CLKN_HB.n29 CLKN_HB.n23 10.9291
R513 CLKN_HB CLKN_HB.n30 9.03615
R514 CLKN_HB.n18 CLKN_HB.n17 9.0005
R515 CLKN_HB.n29 CLKN_HB.n28 9.0005
R516 CLKN_HB.n30 CLKN_HB.n18 8.86606
R517 CLKN_HB.n12 CLKN_HB.n9 7.17687
R518 CLKN_HB.n16 CLKN_HB.n10 7.17687
R519 CLKN_HB.n3 CLKN_HB.n0 7.17687
R520 CLKN_HB.n7 CLKN_HB.n1 7.17687
R521 CLKN_HB.n28 CLKN_HB.n24 7.10487
R522 CLKN_HB.n28 CLKN_HB.n27 7.10487
R523 CLKN_HB.n23 CLKN_HB.n19 7.10487
R524 CLKN_HB.n23 CLKN_HB.n22 7.10487
R525 CLKN_HB.n30 CLKN_HB.n29 4.59693
R526 CLKN_HB.n11 CLKN_HB.n10 4.42851
R527 CLKN_HB.n13 CLKN_HB.n12 4.42851
R528 CLKN_HB.n2 CLKN_HB.n1 4.42851
R529 CLKN_HB.n4 CLKN_HB.n3 4.42851
R530 CLKN_HB.n25 CLKN_HB.n24 4.42851
R531 CLKN_HB.n27 CLKN_HB.n26 4.42851
R532 CLKN_HB.n20 CLKN_HB.n19 4.42851
R533 CLKN_HB.n22 CLKN_HB.n21 4.42851
R534 CLKN_HB.n17 CLKN_HB.n9 0.0485
R535 CLKN_HB.n17 CLKN_HB.n16 0.0485
R536 CLKN_HB.n8 CLKN_HB.n0 0.0485
R537 CLKN_HB.n8 CLKN_HB.n7 0.0485
R538 VDD.t254 VDD.t194 450.829
R539 VDD.t202 VDD.t260 450.829
R540 VDD.t22 VDD.t212 450.829
R541 VDD.t52 VDD.t116 450.829
R542 VDD.t100 VDD.t58 450.829
R543 VDD.t78 VDD.t176 450.829
R544 VDD.t182 VDD.t80 450.829
R545 VDD.t18 VDD.t192 450.829
R546 VDD.t32 VDD.t10 450.829
R547 VDD.t122 VDD.t50 450.829
R548 VDD.t198 VDD.n88 417.582
R549 VDD.t178 VDD.n1 417.582
R550 VDD.n122 VDD.t162 227.625
R551 VDD.n35 VDD.t152 227.625
R552 VDD.n122 VDD.t72 223.204
R553 VDD.n35 VDD.t294 223.204
R554 VDD.t196 VDD.t198 44.1994
R555 VDD.t200 VDD.t196 44.1994
R556 VDD.t194 VDD.t200 44.1994
R557 VDD.t256 VDD.t254 44.1994
R558 VDD.t258 VDD.t256 44.1994
R559 VDD.t260 VDD.t258 44.1994
R560 VDD.t204 VDD.t202 44.1994
R561 VDD.t206 VDD.t204 44.1994
R562 VDD.t210 VDD.t206 44.1994
R563 VDD.t208 VDD.t210 44.1994
R564 VDD.t212 VDD.t208 44.1994
R565 VDD.t20 VDD.t22 44.1994
R566 VDD.t42 VDD.t20 44.1994
R567 VDD.t40 VDD.t42 44.1994
R568 VDD.t66 VDD.t40 44.1994
R569 VDD.t64 VDD.t66 44.1994
R570 VDD.t118 VDD.t64 44.1994
R571 VDD.t116 VDD.t118 44.1994
R572 VDD.t38 VDD.t52 44.1994
R573 VDD.t36 VDD.t38 44.1994
R574 VDD.t114 VDD.t36 44.1994
R575 VDD.t112 VDD.t114 44.1994
R576 VDD.t14 VDD.t112 44.1994
R577 VDD.t12 VDD.t14 44.1994
R578 VDD.t58 VDD.t12 44.1994
R579 VDD.t160 VDD.t100 44.1994
R580 VDD.t158 VDD.t160 44.1994
R581 VDD.t270 VDD.t158 44.1994
R582 VDD.t268 VDD.t270 44.1994
R583 VDD.t142 VDD.t268 44.1994
R584 VDD.t140 VDD.t142 44.1994
R585 VDD.t150 VDD.t140 44.1994
R586 VDD.t148 VDD.t150 44.1994
R587 VDD.t306 VDD.t148 44.1994
R588 VDD.t304 VDD.t306 44.1994
R589 VDD.t88 VDD.t304 44.1994
R590 VDD.t86 VDD.t88 44.1994
R591 VDD.t108 VDD.t86 44.1994
R592 VDD.t106 VDD.t108 44.1994
R593 VDD.t162 VDD.t106 44.1994
R594 VDD.t72 VDD.t102 44.1994
R595 VDD.t102 VDD.t168 44.1994
R596 VDD.t168 VDD.t166 44.1994
R597 VDD.t166 VDD.t164 44.1994
R598 VDD.t164 VDD.t68 44.1994
R599 VDD.t68 VDD.t218 44.1994
R600 VDD.t218 VDD.t170 44.1994
R601 VDD.t170 VDD.t252 44.1994
R602 VDD.t252 VDD.t0 44.1994
R603 VDD.t0 VDD.t56 44.1994
R604 VDD.t56 VDD.t74 44.1994
R605 VDD.t74 VDD.t172 44.1994
R606 VDD.t172 VDD.t76 44.1994
R607 VDD.t76 VDD.t216 44.1994
R608 VDD.t216 VDD.t44 44.1994
R609 VDD.t44 VDD.t2 44.1994
R610 VDD.t2 VDD.t24 44.1994
R611 VDD.t24 VDD.t60 44.1994
R612 VDD.t60 VDD.t46 44.1994
R613 VDD.t46 VDD.t4 44.1994
R614 VDD.t4 VDD.t26 44.1994
R615 VDD.t26 VDD.t62 44.1994
R616 VDD.t62 VDD.t110 44.1994
R617 VDD.t110 VDD.t130 44.1994
R618 VDD.t130 VDD.t98 44.1994
R619 VDD.t98 VDD.t124 44.1994
R620 VDD.t124 VDD.t132 44.1994
R621 VDD.t132 VDD.t70 44.1994
R622 VDD.t70 VDD.t126 44.1994
R623 VDD.t126 VDD.t48 44.1994
R624 VDD.t48 VDD.t6 44.1994
R625 VDD.t174 VDD.t178 44.1994
R626 VDD.t180 VDD.t174 44.1994
R627 VDD.t176 VDD.t180 44.1994
R628 VDD.t82 VDD.t78 44.1994
R629 VDD.t84 VDD.t82 44.1994
R630 VDD.t80 VDD.t84 44.1994
R631 VDD.t184 VDD.t182 44.1994
R632 VDD.t188 VDD.t184 44.1994
R633 VDD.t190 VDD.t188 44.1994
R634 VDD.t186 VDD.t190 44.1994
R635 VDD.t192 VDD.t186 44.1994
R636 VDD.t54 VDD.t18 44.1994
R637 VDD.t16 VDD.t54 44.1994
R638 VDD.t138 VDD.t16 44.1994
R639 VDD.t8 VDD.t138 44.1994
R640 VDD.t156 VDD.t8 44.1994
R641 VDD.t262 VDD.t156 44.1994
R642 VDD.t10 VDD.t262 44.1994
R643 VDD.t30 VDD.t32 44.1994
R644 VDD.t214 VDD.t30 44.1994
R645 VDD.t104 VDD.t214 44.1994
R646 VDD.t128 VDD.t104 44.1994
R647 VDD.t28 VDD.t128 44.1994
R648 VDD.t34 VDD.t28 44.1994
R649 VDD.t50 VDD.t34 44.1994
R650 VDD.t120 VDD.t122 44.1994
R651 VDD.t266 VDD.t120 44.1994
R652 VDD.t264 VDD.t266 44.1994
R653 VDD.t136 VDD.t264 44.1994
R654 VDD.t134 VDD.t136 44.1994
R655 VDD.t146 VDD.t134 44.1994
R656 VDD.t144 VDD.t146 44.1994
R657 VDD.t92 VDD.t144 44.1994
R658 VDD.t90 VDD.t92 44.1994
R659 VDD.t96 VDD.t90 44.1994
R660 VDD.t94 VDD.t96 44.1994
R661 VDD.t310 VDD.t94 44.1994
R662 VDD.t308 VDD.t310 44.1994
R663 VDD.t154 VDD.t308 44.1994
R664 VDD.t152 VDD.t154 44.1994
R665 VDD.t294 VDD.t274 44.1994
R666 VDD.t274 VDD.t272 44.1994
R667 VDD.t272 VDD.t286 44.1994
R668 VDD.t286 VDD.t284 44.1994
R669 VDD.t284 VDD.t278 44.1994
R670 VDD.t278 VDD.t276 44.1994
R671 VDD.t276 VDD.t222 44.1994
R672 VDD.t222 VDD.t220 44.1994
R673 VDD.t220 VDD.t250 44.1994
R674 VDD.t250 VDD.t248 44.1994
R675 VDD.t248 VDD.t238 44.1994
R676 VDD.t238 VDD.t236 44.1994
R677 VDD.t236 VDD.t230 44.1994
R678 VDD.t230 VDD.t228 44.1994
R679 VDD.t228 VDD.t298 44.1994
R680 VDD.t298 VDD.t296 44.1994
R681 VDD.t296 VDD.t290 44.1994
R682 VDD.t290 VDD.t288 44.1994
R683 VDD.t288 VDD.t282 44.1994
R684 VDD.t282 VDD.t280 44.1994
R685 VDD.t280 VDD.t226 44.1994
R686 VDD.t226 VDD.t224 44.1994
R687 VDD.t224 VDD.t246 44.1994
R688 VDD.t246 VDD.t244 44.1994
R689 VDD.t244 VDD.t242 44.1994
R690 VDD.t242 VDD.t240 44.1994
R691 VDD.t240 VDD.t234 44.1994
R692 VDD.t234 VDD.t232 44.1994
R693 VDD.t232 VDD.t302 44.1994
R694 VDD.t302 VDD.t300 44.1994
R695 VDD.t300 VDD.t292 44.1994
R696 VDD.n123 VDD.n122 26.4219
R697 VDD.n36 VDD.n35 26.4219
R698 VDD.n121 VDD.n120 11.8382
R699 VDD.n34 VDD.n33 11.8382
R700 VDD.n140 VDD.n139 11.1661
R701 VDD.n148 VDD.n147 11.1661
R702 VDD.n156 VDD.n155 11.1661
R703 VDD.n162 VDD.n161 11.1661
R704 VDD.n166 VDD.n165 11.1661
R705 VDD.n170 VDD.n169 11.1661
R706 VDD.n53 VDD.n52 11.1661
R707 VDD.n61 VDD.n60 11.1661
R708 VDD.n69 VDD.n68 11.1661
R709 VDD.n75 VDD.n74 11.1661
R710 VDD.n79 VDD.n78 11.1661
R711 VDD.n83 VDD.n82 11.1661
R712 VDD.n92 VDD.n90 5.51014
R713 VDD.n127 VDD.n125 5.51014
R714 VDD.n143 VDD.n141 5.51014
R715 VDD.n151 VDD.n149 5.51014
R716 VDD.n159 VDD.n157 5.51014
R717 VDD.n165 VDD.n163 5.51014
R718 VDD.n169 VDD.n167 5.51014
R719 VDD.n5 VDD.n3 5.51014
R720 VDD.n40 VDD.n38 5.51014
R721 VDD.n56 VDD.n54 5.51014
R722 VDD.n64 VDD.n62 5.51014
R723 VDD.n72 VDD.n70 5.51014
R724 VDD.n78 VDD.n76 5.51014
R725 VDD.n82 VDD.n80 5.51014
R726 VDD.n120 VDD.n119 5.32067
R727 VDD.n118 VDD.n117 5.32067
R728 VDD.n116 VDD.n115 5.32067
R729 VDD.n114 VDD.n113 5.32067
R730 VDD.n112 VDD.n111 5.32067
R731 VDD.n110 VDD.n109 5.32067
R732 VDD.n108 VDD.n107 5.32067
R733 VDD.n106 VDD.n105 5.32067
R734 VDD.n104 VDD.n103 5.32067
R735 VDD.n102 VDD.n101 5.32067
R736 VDD.n100 VDD.n99 5.32067
R737 VDD.n98 VDD.n97 5.32067
R738 VDD.n96 VDD.n95 5.32067
R739 VDD.n94 VDD.n93 5.32067
R740 VDD.n92 VDD.n91 5.32067
R741 VDD.n139 VDD.n138 5.32067
R742 VDD.n137 VDD.n136 5.32067
R743 VDD.n135 VDD.n134 5.32067
R744 VDD.n133 VDD.n132 5.32067
R745 VDD.n131 VDD.n130 5.32067
R746 VDD.n129 VDD.n128 5.32067
R747 VDD.n127 VDD.n126 5.32067
R748 VDD.n147 VDD.n146 5.32067
R749 VDD.n145 VDD.n144 5.32067
R750 VDD.n143 VDD.n142 5.32067
R751 VDD.n155 VDD.n154 5.32067
R752 VDD.n153 VDD.n152 5.32067
R753 VDD.n151 VDD.n150 5.32067
R754 VDD.n161 VDD.n160 5.32067
R755 VDD.n159 VDD.n158 5.32067
R756 VDD.n165 VDD.n164 5.32067
R757 VDD.n169 VDD.n168 5.32067
R758 VDD.n33 VDD.n32 5.32067
R759 VDD.n31 VDD.n30 5.32067
R760 VDD.n29 VDD.n28 5.32067
R761 VDD.n27 VDD.n26 5.32067
R762 VDD.n25 VDD.n24 5.32067
R763 VDD.n23 VDD.n22 5.32067
R764 VDD.n21 VDD.n20 5.32067
R765 VDD.n19 VDD.n18 5.32067
R766 VDD.n17 VDD.n16 5.32067
R767 VDD.n15 VDD.n14 5.32067
R768 VDD.n13 VDD.n12 5.32067
R769 VDD.n11 VDD.n10 5.32067
R770 VDD.n9 VDD.n8 5.32067
R771 VDD.n7 VDD.n6 5.32067
R772 VDD.n5 VDD.n4 5.32067
R773 VDD.n52 VDD.n51 5.32067
R774 VDD.n50 VDD.n49 5.32067
R775 VDD.n48 VDD.n47 5.32067
R776 VDD.n46 VDD.n45 5.32067
R777 VDD.n44 VDD.n43 5.32067
R778 VDD.n42 VDD.n41 5.32067
R779 VDD.n40 VDD.n39 5.32067
R780 VDD.n60 VDD.n59 5.32067
R781 VDD.n58 VDD.n57 5.32067
R782 VDD.n56 VDD.n55 5.32067
R783 VDD.n68 VDD.n67 5.32067
R784 VDD.n66 VDD.n65 5.32067
R785 VDD.n64 VDD.n63 5.32067
R786 VDD.n74 VDD.n73 5.32067
R787 VDD.n72 VDD.n71 5.32067
R788 VDD.n78 VDD.n77 5.32067
R789 VDD.n82 VDD.n81 5.32067
R790 VDD.n87 VDD.n0 4.5005
R791 VDD.n174 VDD.n0 4.5005
R792 VDD.n87 VDD.n86 3.31026
R793 VDD.n174 VDD.n173 2.76928
R794 VDD.n176 VDD.n175 2.26839
R795 VDD.n173 VDD.n172 2.2545
R796 VDD.n121 VDD.n89 2.2545
R797 VDD.n86 VDD.n85 2.2545
R798 VDD.n34 VDD.n2 2.2545
R799 VDD.n172 VDD.n171 2.2505
R800 VDD.n124 VDD.n89 2.2505
R801 VDD.n85 VDD.n84 2.2505
R802 VDD.n37 VDD.n2 2.2505
R803 VDD VDD.n176 1.13544
R804 VDD.n172 VDD.n89 0.5565
R805 VDD.n85 VDD.n2 0.5565
R806 VDD.n148 VDD.n140 0.4541
R807 VDD.n61 VDD.n53 0.4541
R808 VDD.n162 VDD.n156 0.3101
R809 VDD.n156 VDD.n148 0.3101
R810 VDD.n75 VDD.n69 0.3101
R811 VDD.n69 VDD.n61 0.3101
R812 VDD.n166 VDD.n162 0.2741
R813 VDD.n79 VDD.n75 0.2741
R814 VDD.n170 VDD.n166 0.2381
R815 VDD.n83 VDD.n79 0.2381
R816 VDD.n171 VDD.n170 0.236975
R817 VDD.n84 VDD.n83 0.236975
R818 VDD.n119 VDD.t49 0.228
R819 VDD.n119 VDD.t7 0.228
R820 VDD.n117 VDD.t71 0.228
R821 VDD.n117 VDD.t127 0.228
R822 VDD.n115 VDD.t125 0.228
R823 VDD.n115 VDD.t133 0.228
R824 VDD.n113 VDD.t131 0.228
R825 VDD.n113 VDD.t99 0.228
R826 VDD.n111 VDD.t63 0.228
R827 VDD.n111 VDD.t111 0.228
R828 VDD.n109 VDD.t5 0.228
R829 VDD.n109 VDD.t27 0.228
R830 VDD.n107 VDD.t61 0.228
R831 VDD.n107 VDD.t47 0.228
R832 VDD.n105 VDD.t3 0.228
R833 VDD.n105 VDD.t25 0.228
R834 VDD.n103 VDD.t217 0.228
R835 VDD.n103 VDD.t45 0.228
R836 VDD.n101 VDD.t173 0.228
R837 VDD.n101 VDD.t77 0.228
R838 VDD.n99 VDD.t57 0.228
R839 VDD.n99 VDD.t75 0.228
R840 VDD.n97 VDD.t253 0.228
R841 VDD.n97 VDD.t1 0.228
R842 VDD.n95 VDD.t219 0.228
R843 VDD.n95 VDD.t171 0.228
R844 VDD.n93 VDD.t165 0.228
R845 VDD.n93 VDD.t69 0.228
R846 VDD.n91 VDD.t169 0.228
R847 VDD.n91 VDD.t167 0.228
R848 VDD.n90 VDD.t73 0.228
R849 VDD.n90 VDD.t103 0.228
R850 VDD.n138 VDD.t107 0.228
R851 VDD.n138 VDD.t163 0.228
R852 VDD.n136 VDD.t87 0.228
R853 VDD.n136 VDD.t109 0.228
R854 VDD.n134 VDD.t305 0.228
R855 VDD.n134 VDD.t89 0.228
R856 VDD.n132 VDD.t149 0.228
R857 VDD.n132 VDD.t307 0.228
R858 VDD.n130 VDD.t141 0.228
R859 VDD.n130 VDD.t151 0.228
R860 VDD.n128 VDD.t269 0.228
R861 VDD.n128 VDD.t143 0.228
R862 VDD.n126 VDD.t159 0.228
R863 VDD.n126 VDD.t271 0.228
R864 VDD.n125 VDD.t101 0.228
R865 VDD.n125 VDD.t161 0.228
R866 VDD.n146 VDD.t13 0.228
R867 VDD.n146 VDD.t59 0.228
R868 VDD.n144 VDD.t113 0.228
R869 VDD.n144 VDD.t15 0.228
R870 VDD.n142 VDD.t37 0.228
R871 VDD.n142 VDD.t115 0.228
R872 VDD.n141 VDD.t53 0.228
R873 VDD.n141 VDD.t39 0.228
R874 VDD.n154 VDD.t119 0.228
R875 VDD.n154 VDD.t117 0.228
R876 VDD.n152 VDD.t67 0.228
R877 VDD.n152 VDD.t65 0.228
R878 VDD.n150 VDD.t43 0.228
R879 VDD.n150 VDD.t41 0.228
R880 VDD.n149 VDD.t23 0.228
R881 VDD.n149 VDD.t21 0.228
R882 VDD.n160 VDD.t209 0.228
R883 VDD.n160 VDD.t213 0.228
R884 VDD.n158 VDD.t207 0.228
R885 VDD.n158 VDD.t211 0.228
R886 VDD.n157 VDD.t203 0.228
R887 VDD.n157 VDD.t205 0.228
R888 VDD.n164 VDD.t259 0.228
R889 VDD.n164 VDD.t261 0.228
R890 VDD.n163 VDD.t255 0.228
R891 VDD.n163 VDD.t257 0.228
R892 VDD.n168 VDD.t201 0.228
R893 VDD.n168 VDD.t195 0.228
R894 VDD.n167 VDD.t199 0.228
R895 VDD.n167 VDD.t197 0.228
R896 VDD.n32 VDD.t301 0.228
R897 VDD.n32 VDD.t293 0.228
R898 VDD.n30 VDD.t233 0.228
R899 VDD.n30 VDD.t303 0.228
R900 VDD.n28 VDD.t241 0.228
R901 VDD.n28 VDD.t235 0.228
R902 VDD.n26 VDD.t245 0.228
R903 VDD.n26 VDD.t243 0.228
R904 VDD.n24 VDD.t225 0.228
R905 VDD.n24 VDD.t247 0.228
R906 VDD.n22 VDD.t281 0.228
R907 VDD.n22 VDD.t227 0.228
R908 VDD.n20 VDD.t289 0.228
R909 VDD.n20 VDD.t283 0.228
R910 VDD.n18 VDD.t297 0.228
R911 VDD.n18 VDD.t291 0.228
R912 VDD.n16 VDD.t229 0.228
R913 VDD.n16 VDD.t299 0.228
R914 VDD.n14 VDD.t237 0.228
R915 VDD.n14 VDD.t231 0.228
R916 VDD.n12 VDD.t249 0.228
R917 VDD.n12 VDD.t239 0.228
R918 VDD.n10 VDD.t221 0.228
R919 VDD.n10 VDD.t251 0.228
R920 VDD.n8 VDD.t277 0.228
R921 VDD.n8 VDD.t223 0.228
R922 VDD.n6 VDD.t285 0.228
R923 VDD.n6 VDD.t279 0.228
R924 VDD.n4 VDD.t273 0.228
R925 VDD.n4 VDD.t287 0.228
R926 VDD.n3 VDD.t295 0.228
R927 VDD.n3 VDD.t275 0.228
R928 VDD.n51 VDD.t155 0.228
R929 VDD.n51 VDD.t153 0.228
R930 VDD.n49 VDD.t311 0.228
R931 VDD.n49 VDD.t309 0.228
R932 VDD.n47 VDD.t97 0.228
R933 VDD.n47 VDD.t95 0.228
R934 VDD.n45 VDD.t93 0.228
R935 VDD.n45 VDD.t91 0.228
R936 VDD.n43 VDD.t147 0.228
R937 VDD.n43 VDD.t145 0.228
R938 VDD.n41 VDD.t137 0.228
R939 VDD.n41 VDD.t135 0.228
R940 VDD.n39 VDD.t267 0.228
R941 VDD.n39 VDD.t265 0.228
R942 VDD.n38 VDD.t123 0.228
R943 VDD.n38 VDD.t121 0.228
R944 VDD.n59 VDD.t35 0.228
R945 VDD.n59 VDD.t51 0.228
R946 VDD.n57 VDD.t129 0.228
R947 VDD.n57 VDD.t29 0.228
R948 VDD.n55 VDD.t215 0.228
R949 VDD.n55 VDD.t105 0.228
R950 VDD.n54 VDD.t33 0.228
R951 VDD.n54 VDD.t31 0.228
R952 VDD.n67 VDD.t263 0.228
R953 VDD.n67 VDD.t11 0.228
R954 VDD.n65 VDD.t9 0.228
R955 VDD.n65 VDD.t157 0.228
R956 VDD.n63 VDD.t17 0.228
R957 VDD.n63 VDD.t139 0.228
R958 VDD.n62 VDD.t19 0.228
R959 VDD.n62 VDD.t55 0.228
R960 VDD.n73 VDD.t187 0.228
R961 VDD.n73 VDD.t193 0.228
R962 VDD.n71 VDD.t189 0.228
R963 VDD.n71 VDD.t191 0.228
R964 VDD.n70 VDD.t183 0.228
R965 VDD.n70 VDD.t185 0.228
R966 VDD.n77 VDD.t85 0.228
R967 VDD.n77 VDD.t81 0.228
R968 VDD.n76 VDD.t79 0.228
R969 VDD.n76 VDD.t83 0.228
R970 VDD.n81 VDD.t181 0.228
R971 VDD.n81 VDD.t177 0.228
R972 VDD.n80 VDD.t179 0.228
R973 VDD.n80 VDD.t175 0.228
R974 VDD.n94 VDD.n92 0.189974
R975 VDD.n96 VDD.n94 0.189974
R976 VDD.n98 VDD.n96 0.189974
R977 VDD.n100 VDD.n98 0.189974
R978 VDD.n102 VDD.n100 0.189974
R979 VDD.n104 VDD.n102 0.189974
R980 VDD.n106 VDD.n104 0.189974
R981 VDD.n108 VDD.n106 0.189974
R982 VDD.n110 VDD.n108 0.189974
R983 VDD.n112 VDD.n110 0.189974
R984 VDD.n114 VDD.n112 0.189974
R985 VDD.n116 VDD.n114 0.189974
R986 VDD.n118 VDD.n116 0.189974
R987 VDD.n120 VDD.n118 0.189974
R988 VDD.n129 VDD.n127 0.189974
R989 VDD.n131 VDD.n129 0.189974
R990 VDD.n133 VDD.n131 0.189974
R991 VDD.n135 VDD.n133 0.189974
R992 VDD.n137 VDD.n135 0.189974
R993 VDD.n139 VDD.n137 0.189974
R994 VDD.n145 VDD.n143 0.189974
R995 VDD.n147 VDD.n145 0.189974
R996 VDD.n153 VDD.n151 0.189974
R997 VDD.n155 VDD.n153 0.189974
R998 VDD.n161 VDD.n159 0.189974
R999 VDD.n7 VDD.n5 0.189974
R1000 VDD.n9 VDD.n7 0.189974
R1001 VDD.n11 VDD.n9 0.189974
R1002 VDD.n13 VDD.n11 0.189974
R1003 VDD.n15 VDD.n13 0.189974
R1004 VDD.n17 VDD.n15 0.189974
R1005 VDD.n19 VDD.n17 0.189974
R1006 VDD.n21 VDD.n19 0.189974
R1007 VDD.n23 VDD.n21 0.189974
R1008 VDD.n25 VDD.n23 0.189974
R1009 VDD.n27 VDD.n25 0.189974
R1010 VDD.n29 VDD.n27 0.189974
R1011 VDD.n31 VDD.n29 0.189974
R1012 VDD.n33 VDD.n31 0.189974
R1013 VDD.n42 VDD.n40 0.189974
R1014 VDD.n44 VDD.n42 0.189974
R1015 VDD.n46 VDD.n44 0.189974
R1016 VDD.n48 VDD.n46 0.189974
R1017 VDD.n50 VDD.n48 0.189974
R1018 VDD.n52 VDD.n50 0.189974
R1019 VDD.n58 VDD.n56 0.189974
R1020 VDD.n60 VDD.n58 0.189974
R1021 VDD.n66 VDD.n64 0.189974
R1022 VDD.n68 VDD.n66 0.189974
R1023 VDD.n74 VDD.n72 0.189974
R1024 VDD.n140 VDD.n124 0.056525
R1025 VDD.n53 VDD.n37 0.056525
R1026 VDD.n176 VDD.n0 0.020105
R1027 VDD.n173 VDD.n88 0.00725
R1028 VDD.n171 VDD.n88 0.00725
R1029 VDD.n124 VDD.n123 0.00725
R1030 VDD.n123 VDD.n121 0.00725
R1031 VDD.n86 VDD.n1 0.00725
R1032 VDD.n84 VDD.n1 0.00725
R1033 VDD.n37 VDD.n36 0.00725
R1034 VDD.n36 VDD.n34 0.00725
R1035 VDD.n175 VDD.n174 0.0054955
R1036 VDD.n175 VDD.n87 0.0054955
R1037 VSS.n95 VSS.n94 5121.21
R1038 VSS.n183 VSS.n95 5121.21
R1039 VSS.n92 VSS.n91 4481.38
R1040 VSS.n184 VSS.n183 4318.81
R1041 VSS.n93 VSS.n92 3545.45
R1042 VSS.n94 VSS.n93 3545.45
R1043 VSS.t92 VSS.t154 1481.56
R1044 VSS.t156 VSS.t98 1481.56
R1045 VSS.t306 VSS.t172 1481.56
R1046 VSS.t210 VSS.t56 1481.56
R1047 VSS.t256 VSS.t232 1481.56
R1048 VSS.t242 VSS.t186 1481.56
R1049 VSS.t182 VSS.t244 1481.56
R1050 VSS.t128 VSS.t196 1481.56
R1051 VSS.t72 VSS.t18 1481.56
R1052 VSS.t152 VSS.t14 1481.56
R1053 VSS.t162 VSS.n4 1285.47
R1054 VSS.n182 VSS.t184 1285.47
R1055 VSS.n93 VSS.n3 933.913
R1056 VSS.n94 VSS.n2 933.913
R1057 VSS.n92 VSS.n4 907.822
R1058 VSS.n183 VSS.n182 907.822
R1059 VSS.n39 VSS.t108 748.045
R1060 VSS.n133 VSS.t202 748.045
R1061 VSS.n39 VSS.t280 733.519
R1062 VSS.n133 VSS.t24 733.519
R1063 VSS.n185 VSS.n95 351.675
R1064 VSS.t160 VSS.t162 145.251
R1065 VSS.t158 VSS.t160 145.251
R1066 VSS.t154 VSS.t158 145.251
R1067 VSS.t94 VSS.t92 145.251
R1068 VSS.t96 VSS.t94 145.251
R1069 VSS.t98 VSS.t96 145.251
R1070 VSS.t164 VSS.t156 145.251
R1071 VSS.t168 VSS.t164 145.251
R1072 VSS.t170 VSS.t168 145.251
R1073 VSS.t166 VSS.t170 145.251
R1074 VSS.t172 VSS.t166 145.251
R1075 VSS.t112 VSS.t306 145.251
R1076 VSS.t52 VSS.t112 145.251
R1077 VSS.t144 VSS.t52 145.251
R1078 VSS.t64 VSS.t144 145.251
R1079 VSS.t150 VSS.t64 145.251
R1080 VSS.t66 VSS.t150 145.251
R1081 VSS.t56 VSS.t66 145.251
R1082 VSS.t260 VSS.t210 145.251
R1083 VSS.t224 VSS.t260 145.251
R1084 VSS.t204 VSS.t224 145.251
R1085 VSS.t206 VSS.t204 145.251
R1086 VSS.t208 VSS.t206 145.251
R1087 VSS.t258 VSS.t208 145.251
R1088 VSS.t232 VSS.t258 145.251
R1089 VSS.t254 VSS.t256 145.251
R1090 VSS.t142 VSS.t254 145.251
R1091 VSS.t140 VSS.t142 145.251
R1092 VSS.t42 VSS.t140 145.251
R1093 VSS.t40 VSS.t42 145.251
R1094 VSS.t2 VSS.t40 145.251
R1095 VSS.t0 VSS.t2 145.251
R1096 VSS.t148 VSS.t0 145.251
R1097 VSS.t146 VSS.t148 145.251
R1098 VSS.t22 VSS.t146 145.251
R1099 VSS.t20 VSS.t22 145.251
R1100 VSS.t76 VSS.t20 145.251
R1101 VSS.t74 VSS.t76 145.251
R1102 VSS.t110 VSS.t74 145.251
R1103 VSS.t108 VSS.t110 145.251
R1104 VSS.t280 VSS.t270 145.251
R1105 VSS.t270 VSS.t268 145.251
R1106 VSS.t268 VSS.t266 145.251
R1107 VSS.t266 VSS.t238 145.251
R1108 VSS.t238 VSS.t236 145.251
R1109 VSS.t236 VSS.t234 145.251
R1110 VSS.t234 VSS.t216 145.251
R1111 VSS.t216 VSS.t214 145.251
R1112 VSS.t214 VSS.t212 145.251
R1113 VSS.t212 VSS.t298 145.251
R1114 VSS.t298 VSS.t296 145.251
R1115 VSS.t296 VSS.t294 145.251
R1116 VSS.t294 VSS.t286 145.251
R1117 VSS.t286 VSS.t284 145.251
R1118 VSS.t284 VSS.t282 145.251
R1119 VSS.t282 VSS.t276 145.251
R1120 VSS.t276 VSS.t274 145.251
R1121 VSS.t274 VSS.t272 145.251
R1122 VSS.t272 VSS.t230 145.251
R1123 VSS.t230 VSS.t228 145.251
R1124 VSS.t228 VSS.t226 145.251
R1125 VSS.t226 VSS.t222 145.251
R1126 VSS.t222 VSS.t220 145.251
R1127 VSS.t220 VSS.t218 145.251
R1128 VSS.t218 VSS.t304 145.251
R1129 VSS.t304 VSS.t302 145.251
R1130 VSS.t302 VSS.t300 145.251
R1131 VSS.t300 VSS.t292 145.251
R1132 VSS.t292 VSS.t290 145.251
R1133 VSS.t290 VSS.t288 145.251
R1134 VSS.t288 VSS.t278 145.251
R1135 VSS.t180 VSS.t184 145.251
R1136 VSS.t178 VSS.t180 145.251
R1137 VSS.t186 VSS.t178 145.251
R1138 VSS.t246 VSS.t242 145.251
R1139 VSS.t248 VSS.t246 145.251
R1140 VSS.t244 VSS.t248 145.251
R1141 VSS.t188 VSS.t182 145.251
R1142 VSS.t192 VSS.t188 145.251
R1143 VSS.t194 VSS.t192 145.251
R1144 VSS.t190 VSS.t194 145.251
R1145 VSS.t196 VSS.t190 145.251
R1146 VSS.t126 VSS.t128 145.251
R1147 VSS.t116 VSS.t126 145.251
R1148 VSS.t114 VSS.t116 145.251
R1149 VSS.t16 VSS.t114 145.251
R1150 VSS.t62 VSS.t16 145.251
R1151 VSS.t54 VSS.t62 145.251
R1152 VSS.t18 VSS.t54 145.251
R1153 VSS.t60 VSS.t72 145.251
R1154 VSS.t58 VSS.t60 145.251
R1155 VSS.t38 VSS.t58 145.251
R1156 VSS.t36 VSS.t38 145.251
R1157 VSS.t124 VSS.t36 145.251
R1158 VSS.t122 VSS.t124 145.251
R1159 VSS.t14 VSS.t122 145.251
R1160 VSS.t252 VSS.t152 145.251
R1161 VSS.t250 VSS.t252 145.251
R1162 VSS.t12 VSS.t250 145.251
R1163 VSS.t10 VSS.t12 145.251
R1164 VSS.t70 VSS.t10 145.251
R1165 VSS.t68 VSS.t70 145.251
R1166 VSS.t310 VSS.t68 145.251
R1167 VSS.t308 VSS.t310 145.251
R1168 VSS.t102 VSS.t308 145.251
R1169 VSS.t100 VSS.t102 145.251
R1170 VSS.t264 VSS.t100 145.251
R1171 VSS.t262 VSS.t264 145.251
R1172 VSS.t106 VSS.t262 145.251
R1173 VSS.t104 VSS.t106 145.251
R1174 VSS.t202 VSS.t104 145.251
R1175 VSS.t24 VSS.t78 145.251
R1176 VSS.t78 VSS.t118 145.251
R1177 VSS.t118 VSS.t130 145.251
R1178 VSS.t130 VSS.t120 145.251
R1179 VSS.t120 VSS.t240 145.251
R1180 VSS.t240 VSS.t26 145.251
R1181 VSS.t26 VSS.t82 145.251
R1182 VSS.t82 VSS.t80 145.251
R1183 VSS.t80 VSS.t176 145.251
R1184 VSS.t176 VSS.t174 145.251
R1185 VSS.t174 VSS.t134 145.251
R1186 VSS.t134 VSS.t132 145.251
R1187 VSS.t132 VSS.t138 145.251
R1188 VSS.t138 VSS.t136 145.251
R1189 VSS.t136 VSS.t200 145.251
R1190 VSS.t200 VSS.t198 145.251
R1191 VSS.t198 VSS.t30 145.251
R1192 VSS.t30 VSS.t28 145.251
R1193 VSS.t28 VSS.t86 145.251
R1194 VSS.t86 VSS.t84 145.251
R1195 VSS.t84 VSS.t46 145.251
R1196 VSS.t46 VSS.t44 145.251
R1197 VSS.t44 VSS.t6 145.251
R1198 VSS.t6 VSS.t4 145.251
R1199 VSS.t4 VSS.t34 145.251
R1200 VSS.t34 VSS.t32 145.251
R1201 VSS.t32 VSS.t90 145.251
R1202 VSS.t90 VSS.t88 145.251
R1203 VSS.t88 VSS.t50 145.251
R1204 VSS.t50 VSS.t48 145.251
R1205 VSS.t48 VSS.t8 145.251
R1206 VSS.n5 VSS.n4 24.2219
R1207 VSS.n40 VSS.n39 24.2219
R1208 VSS.n182 VSS.n181 24.2219
R1209 VSS.n134 VSS.n133 24.2219
R1210 VSS.n38 VSS.n37 10.6489
R1211 VSS.n132 VSS.n131 10.6489
R1212 VSS.n57 VSS.n56 9.9768
R1213 VSS.n65 VSS.n64 9.9768
R1214 VSS.n73 VSS.n72 9.9768
R1215 VSS.n79 VSS.n78 9.9768
R1216 VSS.n83 VSS.n82 9.9768
R1217 VSS.n87 VSS.n86 9.9768
R1218 VSS.n176 VSS.n175 9.9768
R1219 VSS.n160 VSS.n159 9.9768
R1220 VSS.n152 VSS.n151 9.9768
R1221 VSS.n144 VSS.n143 9.9768
R1222 VSS.n138 VSS.n137 9.9768
R1223 VSS.n100 VSS.n99 9.9768
R1224 VSS.n9 VSS.n7 5.57485
R1225 VSS.n44 VSS.n42 5.57485
R1226 VSS.n60 VSS.n58 5.57485
R1227 VSS.n68 VSS.n66 5.57485
R1228 VSS.n76 VSS.n74 5.57485
R1229 VSS.n82 VSS.n80 5.57485
R1230 VSS.n86 VSS.n84 5.57485
R1231 VSS.n103 VSS.n101 5.57485
R1232 VSS.n163 VSS.n161 5.57485
R1233 VSS.n155 VSS.n153 5.57485
R1234 VSS.n147 VSS.n145 5.57485
R1235 VSS.n141 VSS.n139 5.57485
R1236 VSS.n137 VSS.n135 5.57485
R1237 VSS.n99 VSS.n97 5.57485
R1238 VSS.n37 VSS.n36 5.38537
R1239 VSS.n35 VSS.n34 5.38537
R1240 VSS.n33 VSS.n32 5.38537
R1241 VSS.n31 VSS.n30 5.38537
R1242 VSS.n29 VSS.n28 5.38537
R1243 VSS.n27 VSS.n26 5.38537
R1244 VSS.n25 VSS.n24 5.38537
R1245 VSS.n23 VSS.n22 5.38537
R1246 VSS.n21 VSS.n20 5.38537
R1247 VSS.n19 VSS.n18 5.38537
R1248 VSS.n17 VSS.n16 5.38537
R1249 VSS.n15 VSS.n14 5.38537
R1250 VSS.n13 VSS.n12 5.38537
R1251 VSS.n11 VSS.n10 5.38537
R1252 VSS.n9 VSS.n8 5.38537
R1253 VSS.n56 VSS.n55 5.38537
R1254 VSS.n54 VSS.n53 5.38537
R1255 VSS.n52 VSS.n51 5.38537
R1256 VSS.n50 VSS.n49 5.38537
R1257 VSS.n48 VSS.n47 5.38537
R1258 VSS.n46 VSS.n45 5.38537
R1259 VSS.n44 VSS.n43 5.38537
R1260 VSS.n64 VSS.n63 5.38537
R1261 VSS.n62 VSS.n61 5.38537
R1262 VSS.n60 VSS.n59 5.38537
R1263 VSS.n72 VSS.n71 5.38537
R1264 VSS.n70 VSS.n69 5.38537
R1265 VSS.n68 VSS.n67 5.38537
R1266 VSS.n78 VSS.n77 5.38537
R1267 VSS.n76 VSS.n75 5.38537
R1268 VSS.n82 VSS.n81 5.38537
R1269 VSS.n86 VSS.n85 5.38537
R1270 VSS.n131 VSS.n130 5.38537
R1271 VSS.n129 VSS.n128 5.38537
R1272 VSS.n127 VSS.n126 5.38537
R1273 VSS.n125 VSS.n124 5.38537
R1274 VSS.n123 VSS.n122 5.38537
R1275 VSS.n121 VSS.n120 5.38537
R1276 VSS.n119 VSS.n118 5.38537
R1277 VSS.n117 VSS.n116 5.38537
R1278 VSS.n115 VSS.n114 5.38537
R1279 VSS.n113 VSS.n112 5.38537
R1280 VSS.n111 VSS.n110 5.38537
R1281 VSS.n109 VSS.n108 5.38537
R1282 VSS.n107 VSS.n106 5.38537
R1283 VSS.n105 VSS.n104 5.38537
R1284 VSS.n103 VSS.n102 5.38537
R1285 VSS.n175 VSS.n174 5.38537
R1286 VSS.n173 VSS.n172 5.38537
R1287 VSS.n171 VSS.n170 5.38537
R1288 VSS.n169 VSS.n168 5.38537
R1289 VSS.n167 VSS.n166 5.38537
R1290 VSS.n165 VSS.n164 5.38537
R1291 VSS.n163 VSS.n162 5.38537
R1292 VSS.n159 VSS.n158 5.38537
R1293 VSS.n157 VSS.n156 5.38537
R1294 VSS.n155 VSS.n154 5.38537
R1295 VSS.n151 VSS.n150 5.38537
R1296 VSS.n149 VSS.n148 5.38537
R1297 VSS.n147 VSS.n146 5.38537
R1298 VSS.n143 VSS.n142 5.38537
R1299 VSS.n141 VSS.n140 5.38537
R1300 VSS.n137 VSS.n136 5.38537
R1301 VSS.n99 VSS.n98 5.38537
R1302 VSS.n1 VSS.n0 4.5005
R1303 VSS.n186 VSS.n0 4.5005
R1304 VSS.n188 VSS.n187 2.26839
R1305 VSS.n90 VSS.n89 2.2545
R1306 VSS.n38 VSS.n6 2.2545
R1307 VSS.n179 VSS.n96 2.2545
R1308 VSS.n178 VSS.n132 2.2545
R1309 VSS.n89 VSS.n88 2.2505
R1310 VSS.n41 VSS.n6 2.2505
R1311 VSS.n180 VSS.n179 2.2505
R1312 VSS.n178 VSS.n177 2.2505
R1313 VSS.n91 VSS.n90 1.90124
R1314 VSS.n184 VSS.n96 1.90124
R1315 VSS VSS.n188 1.13544
R1316 VSS.n89 VSS.n6 0.5565
R1317 VSS.n179 VSS.n178 0.5565
R1318 VSS.n91 VSS.n3 0.543479
R1319 VSS.n3 VSS.n2 0.543479
R1320 VSS.n185 VSS.n184 0.543479
R1321 VSS.n2 VSS.n1 0.507615
R1322 VSS.n186 VSS.n185 0.507363
R1323 VSS.n65 VSS.n57 0.4541
R1324 VSS.n176 VSS.n160 0.4541
R1325 VSS.n79 VSS.n73 0.3101
R1326 VSS.n73 VSS.n65 0.3101
R1327 VSS.n152 VSS.n144 0.3101
R1328 VSS.n160 VSS.n152 0.3101
R1329 VSS.n83 VSS.n79 0.2741
R1330 VSS.n144 VSS.n138 0.2741
R1331 VSS.n87 VSS.n83 0.2381
R1332 VSS.n138 VSS.n100 0.2381
R1333 VSS.n88 VSS.n87 0.236975
R1334 VSS.n180 VSS.n100 0.236975
R1335 VSS.n36 VSS.t289 0.20525
R1336 VSS.n36 VSS.t279 0.20525
R1337 VSS.n34 VSS.t293 0.20525
R1338 VSS.n34 VSS.t291 0.20525
R1339 VSS.n32 VSS.t303 0.20525
R1340 VSS.n32 VSS.t301 0.20525
R1341 VSS.n30 VSS.t219 0.20525
R1342 VSS.n30 VSS.t305 0.20525
R1343 VSS.n28 VSS.t223 0.20525
R1344 VSS.n28 VSS.t221 0.20525
R1345 VSS.n26 VSS.t229 0.20525
R1346 VSS.n26 VSS.t227 0.20525
R1347 VSS.n24 VSS.t273 0.20525
R1348 VSS.n24 VSS.t231 0.20525
R1349 VSS.n22 VSS.t277 0.20525
R1350 VSS.n22 VSS.t275 0.20525
R1351 VSS.n20 VSS.t285 0.20525
R1352 VSS.n20 VSS.t283 0.20525
R1353 VSS.n18 VSS.t295 0.20525
R1354 VSS.n18 VSS.t287 0.20525
R1355 VSS.n16 VSS.t299 0.20525
R1356 VSS.n16 VSS.t297 0.20525
R1357 VSS.n14 VSS.t215 0.20525
R1358 VSS.n14 VSS.t213 0.20525
R1359 VSS.n12 VSS.t235 0.20525
R1360 VSS.n12 VSS.t217 0.20525
R1361 VSS.n10 VSS.t239 0.20525
R1362 VSS.n10 VSS.t237 0.20525
R1363 VSS.n8 VSS.t269 0.20525
R1364 VSS.n8 VSS.t267 0.20525
R1365 VSS.n7 VSS.t281 0.20525
R1366 VSS.n7 VSS.t271 0.20525
R1367 VSS.n55 VSS.t111 0.20525
R1368 VSS.n55 VSS.t109 0.20525
R1369 VSS.n53 VSS.t77 0.20525
R1370 VSS.n53 VSS.t75 0.20525
R1371 VSS.n51 VSS.t23 0.20525
R1372 VSS.n51 VSS.t21 0.20525
R1373 VSS.n49 VSS.t149 0.20525
R1374 VSS.n49 VSS.t147 0.20525
R1375 VSS.n47 VSS.t3 0.20525
R1376 VSS.n47 VSS.t1 0.20525
R1377 VSS.n45 VSS.t43 0.20525
R1378 VSS.n45 VSS.t41 0.20525
R1379 VSS.n43 VSS.t143 0.20525
R1380 VSS.n43 VSS.t141 0.20525
R1381 VSS.n42 VSS.t257 0.20525
R1382 VSS.n42 VSS.t255 0.20525
R1383 VSS.n63 VSS.t259 0.20525
R1384 VSS.n63 VSS.t233 0.20525
R1385 VSS.n61 VSS.t207 0.20525
R1386 VSS.n61 VSS.t209 0.20525
R1387 VSS.n59 VSS.t225 0.20525
R1388 VSS.n59 VSS.t205 0.20525
R1389 VSS.n58 VSS.t211 0.20525
R1390 VSS.n58 VSS.t261 0.20525
R1391 VSS.n71 VSS.t67 0.20525
R1392 VSS.n71 VSS.t57 0.20525
R1393 VSS.n69 VSS.t65 0.20525
R1394 VSS.n69 VSS.t151 0.20525
R1395 VSS.n67 VSS.t53 0.20525
R1396 VSS.n67 VSS.t145 0.20525
R1397 VSS.n66 VSS.t307 0.20525
R1398 VSS.n66 VSS.t113 0.20525
R1399 VSS.n77 VSS.t167 0.20525
R1400 VSS.n77 VSS.t173 0.20525
R1401 VSS.n75 VSS.t169 0.20525
R1402 VSS.n75 VSS.t171 0.20525
R1403 VSS.n74 VSS.t157 0.20525
R1404 VSS.n74 VSS.t165 0.20525
R1405 VSS.n81 VSS.t97 0.20525
R1406 VSS.n81 VSS.t99 0.20525
R1407 VSS.n80 VSS.t93 0.20525
R1408 VSS.n80 VSS.t95 0.20525
R1409 VSS.n85 VSS.t159 0.20525
R1410 VSS.n85 VSS.t155 0.20525
R1411 VSS.n84 VSS.t163 0.20525
R1412 VSS.n84 VSS.t161 0.20525
R1413 VSS.n130 VSS.t49 0.20525
R1414 VSS.n130 VSS.t9 0.20525
R1415 VSS.n128 VSS.t89 0.20525
R1416 VSS.n128 VSS.t51 0.20525
R1417 VSS.n126 VSS.t33 0.20525
R1418 VSS.n126 VSS.t91 0.20525
R1419 VSS.n124 VSS.t5 0.20525
R1420 VSS.n124 VSS.t35 0.20525
R1421 VSS.n122 VSS.t45 0.20525
R1422 VSS.n122 VSS.t7 0.20525
R1423 VSS.n120 VSS.t85 0.20525
R1424 VSS.n120 VSS.t47 0.20525
R1425 VSS.n118 VSS.t29 0.20525
R1426 VSS.n118 VSS.t87 0.20525
R1427 VSS.n116 VSS.t199 0.20525
R1428 VSS.n116 VSS.t31 0.20525
R1429 VSS.n114 VSS.t137 0.20525
R1430 VSS.n114 VSS.t201 0.20525
R1431 VSS.n112 VSS.t133 0.20525
R1432 VSS.n112 VSS.t139 0.20525
R1433 VSS.n110 VSS.t175 0.20525
R1434 VSS.n110 VSS.t135 0.20525
R1435 VSS.n108 VSS.t81 0.20525
R1436 VSS.n108 VSS.t177 0.20525
R1437 VSS.n106 VSS.t27 0.20525
R1438 VSS.n106 VSS.t83 0.20525
R1439 VSS.n104 VSS.t121 0.20525
R1440 VSS.n104 VSS.t241 0.20525
R1441 VSS.n102 VSS.t119 0.20525
R1442 VSS.n102 VSS.t131 0.20525
R1443 VSS.n101 VSS.t25 0.20525
R1444 VSS.n101 VSS.t79 0.20525
R1445 VSS.n174 VSS.t105 0.20525
R1446 VSS.n174 VSS.t203 0.20525
R1447 VSS.n172 VSS.t263 0.20525
R1448 VSS.n172 VSS.t107 0.20525
R1449 VSS.n170 VSS.t101 0.20525
R1450 VSS.n170 VSS.t265 0.20525
R1451 VSS.n168 VSS.t309 0.20525
R1452 VSS.n168 VSS.t103 0.20525
R1453 VSS.n166 VSS.t69 0.20525
R1454 VSS.n166 VSS.t311 0.20525
R1455 VSS.n164 VSS.t11 0.20525
R1456 VSS.n164 VSS.t71 0.20525
R1457 VSS.n162 VSS.t251 0.20525
R1458 VSS.n162 VSS.t13 0.20525
R1459 VSS.n161 VSS.t153 0.20525
R1460 VSS.n161 VSS.t253 0.20525
R1461 VSS.n158 VSS.t123 0.20525
R1462 VSS.n158 VSS.t15 0.20525
R1463 VSS.n156 VSS.t37 0.20525
R1464 VSS.n156 VSS.t125 0.20525
R1465 VSS.n154 VSS.t59 0.20525
R1466 VSS.n154 VSS.t39 0.20525
R1467 VSS.n153 VSS.t73 0.20525
R1468 VSS.n153 VSS.t61 0.20525
R1469 VSS.n150 VSS.t55 0.20525
R1470 VSS.n150 VSS.t19 0.20525
R1471 VSS.n148 VSS.t17 0.20525
R1472 VSS.n148 VSS.t63 0.20525
R1473 VSS.n146 VSS.t117 0.20525
R1474 VSS.n146 VSS.t115 0.20525
R1475 VSS.n145 VSS.t129 0.20525
R1476 VSS.n145 VSS.t127 0.20525
R1477 VSS.n142 VSS.t191 0.20525
R1478 VSS.n142 VSS.t197 0.20525
R1479 VSS.n140 VSS.t193 0.20525
R1480 VSS.n140 VSS.t195 0.20525
R1481 VSS.n139 VSS.t183 0.20525
R1482 VSS.n139 VSS.t189 0.20525
R1483 VSS.n136 VSS.t249 0.20525
R1484 VSS.n136 VSS.t245 0.20525
R1485 VSS.n135 VSS.t243 0.20525
R1486 VSS.n135 VSS.t247 0.20525
R1487 VSS.n98 VSS.t179 0.20525
R1488 VSS.n98 VSS.t187 0.20525
R1489 VSS.n97 VSS.t185 0.20525
R1490 VSS.n97 VSS.t181 0.20525
R1491 VSS.n11 VSS.n9 0.189974
R1492 VSS.n13 VSS.n11 0.189974
R1493 VSS.n15 VSS.n13 0.189974
R1494 VSS.n17 VSS.n15 0.189974
R1495 VSS.n19 VSS.n17 0.189974
R1496 VSS.n21 VSS.n19 0.189974
R1497 VSS.n23 VSS.n21 0.189974
R1498 VSS.n25 VSS.n23 0.189974
R1499 VSS.n27 VSS.n25 0.189974
R1500 VSS.n29 VSS.n27 0.189974
R1501 VSS.n31 VSS.n29 0.189974
R1502 VSS.n33 VSS.n31 0.189974
R1503 VSS.n35 VSS.n33 0.189974
R1504 VSS.n37 VSS.n35 0.189974
R1505 VSS.n46 VSS.n44 0.189974
R1506 VSS.n48 VSS.n46 0.189974
R1507 VSS.n50 VSS.n48 0.189974
R1508 VSS.n52 VSS.n50 0.189974
R1509 VSS.n54 VSS.n52 0.189974
R1510 VSS.n56 VSS.n54 0.189974
R1511 VSS.n62 VSS.n60 0.189974
R1512 VSS.n64 VSS.n62 0.189974
R1513 VSS.n70 VSS.n68 0.189974
R1514 VSS.n72 VSS.n70 0.189974
R1515 VSS.n78 VSS.n76 0.189974
R1516 VSS.n105 VSS.n103 0.189974
R1517 VSS.n107 VSS.n105 0.189974
R1518 VSS.n109 VSS.n107 0.189974
R1519 VSS.n111 VSS.n109 0.189974
R1520 VSS.n113 VSS.n111 0.189974
R1521 VSS.n115 VSS.n113 0.189974
R1522 VSS.n117 VSS.n115 0.189974
R1523 VSS.n119 VSS.n117 0.189974
R1524 VSS.n121 VSS.n119 0.189974
R1525 VSS.n123 VSS.n121 0.189974
R1526 VSS.n125 VSS.n123 0.189974
R1527 VSS.n127 VSS.n125 0.189974
R1528 VSS.n129 VSS.n127 0.189974
R1529 VSS.n131 VSS.n129 0.189974
R1530 VSS.n165 VSS.n163 0.189974
R1531 VSS.n167 VSS.n165 0.189974
R1532 VSS.n169 VSS.n167 0.189974
R1533 VSS.n171 VSS.n169 0.189974
R1534 VSS.n173 VSS.n171 0.189974
R1535 VSS.n175 VSS.n173 0.189974
R1536 VSS.n157 VSS.n155 0.189974
R1537 VSS.n159 VSS.n157 0.189974
R1538 VSS.n149 VSS.n147 0.189974
R1539 VSS.n151 VSS.n149 0.189974
R1540 VSS.n143 VSS.n141 0.189974
R1541 VSS.n57 VSS.n41 0.056525
R1542 VSS.n177 VSS.n176 0.056525
R1543 VSS.n188 VSS.n0 0.020105
R1544 VSS.n90 VSS.n5 0.00725
R1545 VSS.n88 VSS.n5 0.00725
R1546 VSS.n41 VSS.n40 0.00725
R1547 VSS.n40 VSS.n38 0.00725
R1548 VSS.n181 VSS.n96 0.00725
R1549 VSS.n181 VSS.n180 0.00725
R1550 VSS.n177 VSS.n134 0.00725
R1551 VSS.n134 VSS.n132 0.00725
R1552 VSS.n187 VSS.n186 0.0054955
R1553 VSS.n187 VSS.n1 0.0054955
R1554 a_14860_6400.n96 a_14860_6400.t63 113.632
R1555 a_14860_6400.n118 a_14860_6400.t32 113.632
R1556 a_14860_6400.n35 a_14860_6400.t95 113.632
R1557 a_14860_6400.n57 a_14860_6400.t64 113.632
R1558 a_14860_6400.n139 a_14860_6400.t47 109.174
R1559 a_14860_6400.n140 a_14860_6400.t48 109.174
R1560 a_14860_6400.n97 a_14860_6400.t62 109.174
R1561 a_14860_6400.n98 a_14860_6400.t61 109.174
R1562 a_14860_6400.n99 a_14860_6400.t60 109.174
R1563 a_14860_6400.n100 a_14860_6400.t59 109.174
R1564 a_14860_6400.n101 a_14860_6400.t58 109.174
R1565 a_14860_6400.n102 a_14860_6400.t57 109.174
R1566 a_14860_6400.n103 a_14860_6400.t56 109.174
R1567 a_14860_6400.n104 a_14860_6400.t55 109.174
R1568 a_14860_6400.n105 a_14860_6400.t54 109.174
R1569 a_14860_6400.n106 a_14860_6400.t53 109.174
R1570 a_14860_6400.n107 a_14860_6400.t52 109.174
R1571 a_14860_6400.n108 a_14860_6400.t51 109.174
R1572 a_14860_6400.n109 a_14860_6400.t50 109.174
R1573 a_14860_6400.n110 a_14860_6400.t49 109.174
R1574 a_14860_6400.n138 a_14860_6400.t46 109.174
R1575 a_14860_6400.n111 a_14860_6400.t45 109.174
R1576 a_14860_6400.n134 a_14860_6400.t44 109.174
R1577 a_14860_6400.n133 a_14860_6400.t43 109.174
R1578 a_14860_6400.n132 a_14860_6400.t42 109.174
R1579 a_14860_6400.n113 a_14860_6400.t41 109.174
R1580 a_14860_6400.n128 a_14860_6400.t40 109.174
R1581 a_14860_6400.n127 a_14860_6400.t39 109.174
R1582 a_14860_6400.n126 a_14860_6400.t38 109.174
R1583 a_14860_6400.n115 a_14860_6400.t37 109.174
R1584 a_14860_6400.n122 a_14860_6400.t36 109.174
R1585 a_14860_6400.n121 a_14860_6400.t35 109.174
R1586 a_14860_6400.n120 a_14860_6400.t34 109.174
R1587 a_14860_6400.n117 a_14860_6400.t33 109.174
R1588 a_14860_6400.n78 a_14860_6400.t79 109.174
R1589 a_14860_6400.n79 a_14860_6400.t80 109.174
R1590 a_14860_6400.n36 a_14860_6400.t94 109.174
R1591 a_14860_6400.n37 a_14860_6400.t93 109.174
R1592 a_14860_6400.n38 a_14860_6400.t92 109.174
R1593 a_14860_6400.n39 a_14860_6400.t91 109.174
R1594 a_14860_6400.n40 a_14860_6400.t90 109.174
R1595 a_14860_6400.n41 a_14860_6400.t89 109.174
R1596 a_14860_6400.n42 a_14860_6400.t88 109.174
R1597 a_14860_6400.n43 a_14860_6400.t87 109.174
R1598 a_14860_6400.n44 a_14860_6400.t86 109.174
R1599 a_14860_6400.n45 a_14860_6400.t85 109.174
R1600 a_14860_6400.n46 a_14860_6400.t84 109.174
R1601 a_14860_6400.n47 a_14860_6400.t83 109.174
R1602 a_14860_6400.n48 a_14860_6400.t82 109.174
R1603 a_14860_6400.n49 a_14860_6400.t81 109.174
R1604 a_14860_6400.n77 a_14860_6400.t78 109.174
R1605 a_14860_6400.n50 a_14860_6400.t77 109.174
R1606 a_14860_6400.n73 a_14860_6400.t76 109.174
R1607 a_14860_6400.n72 a_14860_6400.t75 109.174
R1608 a_14860_6400.n71 a_14860_6400.t74 109.174
R1609 a_14860_6400.n52 a_14860_6400.t73 109.174
R1610 a_14860_6400.n67 a_14860_6400.t72 109.174
R1611 a_14860_6400.n66 a_14860_6400.t71 109.174
R1612 a_14860_6400.n65 a_14860_6400.t70 109.174
R1613 a_14860_6400.n54 a_14860_6400.t69 109.174
R1614 a_14860_6400.n61 a_14860_6400.t68 109.174
R1615 a_14860_6400.n60 a_14860_6400.t67 109.174
R1616 a_14860_6400.n59 a_14860_6400.t66 109.174
R1617 a_14860_6400.n56 a_14860_6400.t65 109.174
R1618 a_14860_6400.n139 a_14860_6400.n82 18.4942
R1619 a_14860_6400.n141 a_14860_6400.n140 18.4942
R1620 a_14860_6400.n98 a_14860_6400.n95 18.4942
R1621 a_14860_6400.n99 a_14860_6400.n94 18.4942
R1622 a_14860_6400.n100 a_14860_6400.n93 18.4942
R1623 a_14860_6400.n101 a_14860_6400.n92 18.4942
R1624 a_14860_6400.n102 a_14860_6400.n91 18.4942
R1625 a_14860_6400.n103 a_14860_6400.n90 18.4942
R1626 a_14860_6400.n104 a_14860_6400.n89 18.4942
R1627 a_14860_6400.n105 a_14860_6400.n88 18.4942
R1628 a_14860_6400.n106 a_14860_6400.n87 18.4942
R1629 a_14860_6400.n107 a_14860_6400.n86 18.4942
R1630 a_14860_6400.n108 a_14860_6400.n85 18.4942
R1631 a_14860_6400.n109 a_14860_6400.n84 18.4942
R1632 a_14860_6400.n110 a_14860_6400.n83 18.4942
R1633 a_14860_6400.n138 a_14860_6400.n137 18.4942
R1634 a_14860_6400.n136 a_14860_6400.n111 18.4942
R1635 a_14860_6400.n135 a_14860_6400.n134 18.4942
R1636 a_14860_6400.n133 a_14860_6400.n112 18.4942
R1637 a_14860_6400.n132 a_14860_6400.n131 18.4942
R1638 a_14860_6400.n130 a_14860_6400.n113 18.4942
R1639 a_14860_6400.n129 a_14860_6400.n128 18.4942
R1640 a_14860_6400.n127 a_14860_6400.n114 18.4942
R1641 a_14860_6400.n126 a_14860_6400.n125 18.4942
R1642 a_14860_6400.n124 a_14860_6400.n115 18.4942
R1643 a_14860_6400.n123 a_14860_6400.n122 18.4942
R1644 a_14860_6400.n121 a_14860_6400.n116 18.4942
R1645 a_14860_6400.n120 a_14860_6400.n119 18.4942
R1646 a_14860_6400.n78 a_14860_6400.n21 18.4942
R1647 a_14860_6400.n80 a_14860_6400.n79 18.4942
R1648 a_14860_6400.n37 a_14860_6400.n34 18.4942
R1649 a_14860_6400.n38 a_14860_6400.n33 18.4942
R1650 a_14860_6400.n39 a_14860_6400.n32 18.4942
R1651 a_14860_6400.n40 a_14860_6400.n31 18.4942
R1652 a_14860_6400.n41 a_14860_6400.n30 18.4942
R1653 a_14860_6400.n42 a_14860_6400.n29 18.4942
R1654 a_14860_6400.n43 a_14860_6400.n28 18.4942
R1655 a_14860_6400.n44 a_14860_6400.n27 18.4942
R1656 a_14860_6400.n45 a_14860_6400.n26 18.4942
R1657 a_14860_6400.n46 a_14860_6400.n25 18.4942
R1658 a_14860_6400.n47 a_14860_6400.n24 18.4942
R1659 a_14860_6400.n48 a_14860_6400.n23 18.4942
R1660 a_14860_6400.n49 a_14860_6400.n22 18.4942
R1661 a_14860_6400.n77 a_14860_6400.n76 18.4942
R1662 a_14860_6400.n75 a_14860_6400.n50 18.4942
R1663 a_14860_6400.n74 a_14860_6400.n73 18.4942
R1664 a_14860_6400.n72 a_14860_6400.n51 18.4942
R1665 a_14860_6400.n71 a_14860_6400.n70 18.4942
R1666 a_14860_6400.n69 a_14860_6400.n52 18.4942
R1667 a_14860_6400.n68 a_14860_6400.n67 18.4942
R1668 a_14860_6400.n66 a_14860_6400.n53 18.4942
R1669 a_14860_6400.n65 a_14860_6400.n64 18.4942
R1670 a_14860_6400.n63 a_14860_6400.n54 18.4942
R1671 a_14860_6400.n62 a_14860_6400.n61 18.4942
R1672 a_14860_6400.n60 a_14860_6400.n55 18.4942
R1673 a_14860_6400.n59 a_14860_6400.n58 18.4942
R1674 a_14860_6400.n144 a_14860_6400.n143 16.6402
R1675 a_14860_6400.n139 a_14860_6400.n138 11.6805
R1676 a_14860_6400.n140 a_14860_6400.n139 11.6805
R1677 a_14860_6400.n98 a_14860_6400.n97 11.6805
R1678 a_14860_6400.n99 a_14860_6400.n98 11.6805
R1679 a_14860_6400.n100 a_14860_6400.n99 11.6805
R1680 a_14860_6400.n101 a_14860_6400.n100 11.6805
R1681 a_14860_6400.n102 a_14860_6400.n101 11.6805
R1682 a_14860_6400.n103 a_14860_6400.n102 11.6805
R1683 a_14860_6400.n104 a_14860_6400.n103 11.6805
R1684 a_14860_6400.n105 a_14860_6400.n104 11.6805
R1685 a_14860_6400.n106 a_14860_6400.n105 11.6805
R1686 a_14860_6400.n107 a_14860_6400.n106 11.6805
R1687 a_14860_6400.n108 a_14860_6400.n107 11.6805
R1688 a_14860_6400.n109 a_14860_6400.n108 11.6805
R1689 a_14860_6400.n110 a_14860_6400.n109 11.6805
R1690 a_14860_6400.n140 a_14860_6400.n110 11.6805
R1691 a_14860_6400.n138 a_14860_6400.n111 11.6805
R1692 a_14860_6400.n134 a_14860_6400.n111 11.6805
R1693 a_14860_6400.n134 a_14860_6400.n133 11.6805
R1694 a_14860_6400.n133 a_14860_6400.n132 11.6805
R1695 a_14860_6400.n132 a_14860_6400.n113 11.6805
R1696 a_14860_6400.n128 a_14860_6400.n113 11.6805
R1697 a_14860_6400.n128 a_14860_6400.n127 11.6805
R1698 a_14860_6400.n127 a_14860_6400.n126 11.6805
R1699 a_14860_6400.n126 a_14860_6400.n115 11.6805
R1700 a_14860_6400.n122 a_14860_6400.n115 11.6805
R1701 a_14860_6400.n122 a_14860_6400.n121 11.6805
R1702 a_14860_6400.n121 a_14860_6400.n120 11.6805
R1703 a_14860_6400.n120 a_14860_6400.n117 11.6805
R1704 a_14860_6400.n78 a_14860_6400.n77 11.6805
R1705 a_14860_6400.n79 a_14860_6400.n78 11.6805
R1706 a_14860_6400.n37 a_14860_6400.n36 11.6805
R1707 a_14860_6400.n38 a_14860_6400.n37 11.6805
R1708 a_14860_6400.n39 a_14860_6400.n38 11.6805
R1709 a_14860_6400.n40 a_14860_6400.n39 11.6805
R1710 a_14860_6400.n41 a_14860_6400.n40 11.6805
R1711 a_14860_6400.n42 a_14860_6400.n41 11.6805
R1712 a_14860_6400.n43 a_14860_6400.n42 11.6805
R1713 a_14860_6400.n44 a_14860_6400.n43 11.6805
R1714 a_14860_6400.n45 a_14860_6400.n44 11.6805
R1715 a_14860_6400.n46 a_14860_6400.n45 11.6805
R1716 a_14860_6400.n47 a_14860_6400.n46 11.6805
R1717 a_14860_6400.n48 a_14860_6400.n47 11.6805
R1718 a_14860_6400.n49 a_14860_6400.n48 11.6805
R1719 a_14860_6400.n79 a_14860_6400.n49 11.6805
R1720 a_14860_6400.n77 a_14860_6400.n50 11.6805
R1721 a_14860_6400.n73 a_14860_6400.n50 11.6805
R1722 a_14860_6400.n73 a_14860_6400.n72 11.6805
R1723 a_14860_6400.n72 a_14860_6400.n71 11.6805
R1724 a_14860_6400.n71 a_14860_6400.n52 11.6805
R1725 a_14860_6400.n67 a_14860_6400.n52 11.6805
R1726 a_14860_6400.n67 a_14860_6400.n66 11.6805
R1727 a_14860_6400.n66 a_14860_6400.n65 11.6805
R1728 a_14860_6400.n65 a_14860_6400.n54 11.6805
R1729 a_14860_6400.n61 a_14860_6400.n54 11.6805
R1730 a_14860_6400.n61 a_14860_6400.n60 11.6805
R1731 a_14860_6400.n60 a_14860_6400.n59 11.6805
R1732 a_14860_6400.n59 a_14860_6400.n56 11.6805
R1733 a_14860_6400.n143 a_14860_6400.n81 10.688
R1734 a_14860_6400.n143 a_14860_6400.n142 9.24157
R1735 a_14860_6400.n119 a_14860_6400.n118 7.17687
R1736 a_14860_6400.n96 a_14860_6400.n95 7.17687
R1737 a_14860_6400.n58 a_14860_6400.n57 7.17687
R1738 a_14860_6400.n35 a_14860_6400.n34 7.17687
R1739 a_14860_6400.n144 a_14860_6400.n20 6.5392
R1740 a_14860_6400.n1 a_14860_6400.t10 5.7796
R1741 a_14860_6400.n7 a_14860_6400.t24 5.73764
R1742 a_14860_6400.n145 a_14860_6400.t29 5.59012
R1743 a_14860_6400.n20 a_14860_6400.t15 5.54817
R1744 a_14860_6400.n153 a_14860_6400.n152 5.38537
R1745 a_14860_6400.n1 a_14860_6400.n0 5.38537
R1746 a_14860_6400.n3 a_14860_6400.n2 5.38537
R1747 a_14860_6400.n5 a_14860_6400.n4 5.38537
R1748 a_14860_6400.n151 a_14860_6400.n150 5.38537
R1749 a_14860_6400.n149 a_14860_6400.n148 5.38537
R1750 a_14860_6400.n147 a_14860_6400.n146 5.38537
R1751 a_14860_6400.n7 a_14860_6400.n6 5.32067
R1752 a_14860_6400.n9 a_14860_6400.n8 5.32067
R1753 a_14860_6400.n11 a_14860_6400.n10 5.32067
R1754 a_14860_6400.n13 a_14860_6400.n12 5.32067
R1755 a_14860_6400.n15 a_14860_6400.n14 5.32067
R1756 a_14860_6400.n17 a_14860_6400.n16 5.32067
R1757 a_14860_6400.n19 a_14860_6400.n18 5.32067
R1758 a_14860_6400.n145 a_14860_6400.n144 4.61063
R1759 a_14860_6400.n97 a_14860_6400.n96 4.42851
R1760 a_14860_6400.n118 a_14860_6400.n117 4.42851
R1761 a_14860_6400.n36 a_14860_6400.n35 4.42851
R1762 a_14860_6400.n57 a_14860_6400.n56 4.42851
R1763 a_14860_6400.n6 a_14860_6400.t30 0.228
R1764 a_14860_6400.n6 a_14860_6400.t25 0.228
R1765 a_14860_6400.n8 a_14860_6400.t12 0.228
R1766 a_14860_6400.n8 a_14860_6400.t31 0.228
R1767 a_14860_6400.n10 a_14860_6400.t8 0.228
R1768 a_14860_6400.n10 a_14860_6400.t13 0.228
R1769 a_14860_6400.n12 a_14860_6400.t20 0.228
R1770 a_14860_6400.n12 a_14860_6400.t9 0.228
R1771 a_14860_6400.n14 a_14860_6400.t16 0.228
R1772 a_14860_6400.n14 a_14860_6400.t21 0.228
R1773 a_14860_6400.n16 a_14860_6400.t26 0.228
R1774 a_14860_6400.n16 a_14860_6400.t17 0.228
R1775 a_14860_6400.n18 a_14860_6400.t14 0.228
R1776 a_14860_6400.n18 a_14860_6400.t27 0.228
R1777 a_14860_6400.t0 a_14860_6400.n153 0.20525
R1778 a_14860_6400.n153 a_14860_6400.t23 0.20525
R1779 a_14860_6400.n0 a_14860_6400.t6 0.20525
R1780 a_14860_6400.n0 a_14860_6400.t11 0.20525
R1781 a_14860_6400.n2 a_14860_6400.t2 0.20525
R1782 a_14860_6400.n2 a_14860_6400.t7 0.20525
R1783 a_14860_6400.n4 a_14860_6400.t22 0.20525
R1784 a_14860_6400.n4 a_14860_6400.t3 0.20525
R1785 a_14860_6400.n150 a_14860_6400.t4 0.20525
R1786 a_14860_6400.n150 a_14860_6400.t1 0.20525
R1787 a_14860_6400.n148 a_14860_6400.t18 0.20525
R1788 a_14860_6400.n148 a_14860_6400.t5 0.20525
R1789 a_14860_6400.n146 a_14860_6400.t28 0.20525
R1790 a_14860_6400.n146 a_14860_6400.t19 0.20525
R1791 a_14860_6400.n147 a_14860_6400.n145 0.189974
R1792 a_14860_6400.n149 a_14860_6400.n147 0.189974
R1793 a_14860_6400.n151 a_14860_6400.n149 0.189974
R1794 a_14860_6400.n152 a_14860_6400.n151 0.189974
R1795 a_14860_6400.n152 a_14860_6400.n5 0.189974
R1796 a_14860_6400.n5 a_14860_6400.n3 0.189974
R1797 a_14860_6400.n3 a_14860_6400.n1 0.189974
R1798 a_14860_6400.n20 a_14860_6400.n19 0.189974
R1799 a_14860_6400.n19 a_14860_6400.n17 0.189974
R1800 a_14860_6400.n17 a_14860_6400.n15 0.189974
R1801 a_14860_6400.n15 a_14860_6400.n13 0.189974
R1802 a_14860_6400.n13 a_14860_6400.n11 0.189974
R1803 a_14860_6400.n11 a_14860_6400.n9 0.189974
R1804 a_14860_6400.n9 a_14860_6400.n7 0.189974
R1805 a_14860_6400.n137 a_14860_6400.n82 0.1205
R1806 a_14860_6400.n137 a_14860_6400.n136 0.1205
R1807 a_14860_6400.n136 a_14860_6400.n135 0.1205
R1808 a_14860_6400.n135 a_14860_6400.n112 0.1205
R1809 a_14860_6400.n131 a_14860_6400.n112 0.1205
R1810 a_14860_6400.n131 a_14860_6400.n130 0.1205
R1811 a_14860_6400.n130 a_14860_6400.n129 0.1205
R1812 a_14860_6400.n129 a_14860_6400.n114 0.1205
R1813 a_14860_6400.n125 a_14860_6400.n114 0.1205
R1814 a_14860_6400.n125 a_14860_6400.n124 0.1205
R1815 a_14860_6400.n124 a_14860_6400.n123 0.1205
R1816 a_14860_6400.n123 a_14860_6400.n116 0.1205
R1817 a_14860_6400.n119 a_14860_6400.n116 0.1205
R1818 a_14860_6400.n95 a_14860_6400.n94 0.1205
R1819 a_14860_6400.n94 a_14860_6400.n93 0.1205
R1820 a_14860_6400.n93 a_14860_6400.n92 0.1205
R1821 a_14860_6400.n92 a_14860_6400.n91 0.1205
R1822 a_14860_6400.n91 a_14860_6400.n90 0.1205
R1823 a_14860_6400.n90 a_14860_6400.n89 0.1205
R1824 a_14860_6400.n89 a_14860_6400.n88 0.1205
R1825 a_14860_6400.n88 a_14860_6400.n87 0.1205
R1826 a_14860_6400.n87 a_14860_6400.n86 0.1205
R1827 a_14860_6400.n86 a_14860_6400.n85 0.1205
R1828 a_14860_6400.n85 a_14860_6400.n84 0.1205
R1829 a_14860_6400.n84 a_14860_6400.n83 0.1205
R1830 a_14860_6400.n141 a_14860_6400.n83 0.1205
R1831 a_14860_6400.n76 a_14860_6400.n21 0.1205
R1832 a_14860_6400.n76 a_14860_6400.n75 0.1205
R1833 a_14860_6400.n75 a_14860_6400.n74 0.1205
R1834 a_14860_6400.n74 a_14860_6400.n51 0.1205
R1835 a_14860_6400.n70 a_14860_6400.n51 0.1205
R1836 a_14860_6400.n70 a_14860_6400.n69 0.1205
R1837 a_14860_6400.n69 a_14860_6400.n68 0.1205
R1838 a_14860_6400.n68 a_14860_6400.n53 0.1205
R1839 a_14860_6400.n64 a_14860_6400.n53 0.1205
R1840 a_14860_6400.n64 a_14860_6400.n63 0.1205
R1841 a_14860_6400.n63 a_14860_6400.n62 0.1205
R1842 a_14860_6400.n62 a_14860_6400.n55 0.1205
R1843 a_14860_6400.n58 a_14860_6400.n55 0.1205
R1844 a_14860_6400.n34 a_14860_6400.n33 0.1205
R1845 a_14860_6400.n33 a_14860_6400.n32 0.1205
R1846 a_14860_6400.n32 a_14860_6400.n31 0.1205
R1847 a_14860_6400.n31 a_14860_6400.n30 0.1205
R1848 a_14860_6400.n30 a_14860_6400.n29 0.1205
R1849 a_14860_6400.n29 a_14860_6400.n28 0.1205
R1850 a_14860_6400.n28 a_14860_6400.n27 0.1205
R1851 a_14860_6400.n27 a_14860_6400.n26 0.1205
R1852 a_14860_6400.n26 a_14860_6400.n25 0.1205
R1853 a_14860_6400.n25 a_14860_6400.n24 0.1205
R1854 a_14860_6400.n24 a_14860_6400.n23 0.1205
R1855 a_14860_6400.n23 a_14860_6400.n22 0.1205
R1856 a_14860_6400.n80 a_14860_6400.n22 0.1205
R1857 a_14860_6400.n142 a_14860_6400.n82 0.0485
R1858 a_14860_6400.n142 a_14860_6400.n141 0.0485
R1859 a_14860_6400.n81 a_14860_6400.n21 0.0485
R1860 a_14860_6400.n81 a_14860_6400.n80 0.0485
R1861 a_6924_6400.n40 a_6924_6400.t27 113.632
R1862 a_6924_6400.n50 a_6924_6400.t12 113.632
R1863 a_6924_6400.n11 a_6924_6400.t43 113.632
R1864 a_6924_6400.n21 a_6924_6400.t28 113.632
R1865 a_6924_6400.n59 a_6924_6400.t19 109.174
R1866 a_6924_6400.n60 a_6924_6400.t20 109.174
R1867 a_6924_6400.n41 a_6924_6400.t26 109.174
R1868 a_6924_6400.n42 a_6924_6400.t25 109.174
R1869 a_6924_6400.n43 a_6924_6400.t24 109.174
R1870 a_6924_6400.n44 a_6924_6400.t23 109.174
R1871 a_6924_6400.n45 a_6924_6400.t22 109.174
R1872 a_6924_6400.n46 a_6924_6400.t21 109.174
R1873 a_6924_6400.n58 a_6924_6400.t18 109.174
R1874 a_6924_6400.n47 a_6924_6400.t17 109.174
R1875 a_6924_6400.n54 a_6924_6400.t16 109.174
R1876 a_6924_6400.n53 a_6924_6400.t15 109.174
R1877 a_6924_6400.n52 a_6924_6400.t14 109.174
R1878 a_6924_6400.n49 a_6924_6400.t13 109.174
R1879 a_6924_6400.n30 a_6924_6400.t35 109.174
R1880 a_6924_6400.n31 a_6924_6400.t36 109.174
R1881 a_6924_6400.n12 a_6924_6400.t42 109.174
R1882 a_6924_6400.n13 a_6924_6400.t41 109.174
R1883 a_6924_6400.n14 a_6924_6400.t40 109.174
R1884 a_6924_6400.n15 a_6924_6400.t39 109.174
R1885 a_6924_6400.n16 a_6924_6400.t38 109.174
R1886 a_6924_6400.n17 a_6924_6400.t37 109.174
R1887 a_6924_6400.n29 a_6924_6400.t34 109.174
R1888 a_6924_6400.n18 a_6924_6400.t33 109.174
R1889 a_6924_6400.n25 a_6924_6400.t32 109.174
R1890 a_6924_6400.n24 a_6924_6400.t31 109.174
R1891 a_6924_6400.n23 a_6924_6400.t30 109.174
R1892 a_6924_6400.n20 a_6924_6400.t29 109.174
R1893 a_6924_6400.n64 a_6924_6400.n63 18.5321
R1894 a_6924_6400.n59 a_6924_6400.n34 18.4942
R1895 a_6924_6400.n61 a_6924_6400.n60 18.4942
R1896 a_6924_6400.n42 a_6924_6400.n39 18.4942
R1897 a_6924_6400.n43 a_6924_6400.n38 18.4942
R1898 a_6924_6400.n44 a_6924_6400.n37 18.4942
R1899 a_6924_6400.n45 a_6924_6400.n36 18.4942
R1900 a_6924_6400.n46 a_6924_6400.n35 18.4942
R1901 a_6924_6400.n58 a_6924_6400.n57 18.4942
R1902 a_6924_6400.n56 a_6924_6400.n47 18.4942
R1903 a_6924_6400.n55 a_6924_6400.n54 18.4942
R1904 a_6924_6400.n53 a_6924_6400.n48 18.4942
R1905 a_6924_6400.n52 a_6924_6400.n51 18.4942
R1906 a_6924_6400.n30 a_6924_6400.n5 18.4942
R1907 a_6924_6400.n32 a_6924_6400.n31 18.4942
R1908 a_6924_6400.n13 a_6924_6400.n10 18.4942
R1909 a_6924_6400.n14 a_6924_6400.n9 18.4942
R1910 a_6924_6400.n15 a_6924_6400.n8 18.4942
R1911 a_6924_6400.n16 a_6924_6400.n7 18.4942
R1912 a_6924_6400.n17 a_6924_6400.n6 18.4942
R1913 a_6924_6400.n29 a_6924_6400.n28 18.4942
R1914 a_6924_6400.n27 a_6924_6400.n18 18.4942
R1915 a_6924_6400.n26 a_6924_6400.n25 18.4942
R1916 a_6924_6400.n24 a_6924_6400.n19 18.4942
R1917 a_6924_6400.n23 a_6924_6400.n22 18.4942
R1918 a_6924_6400.n59 a_6924_6400.n58 11.6805
R1919 a_6924_6400.n60 a_6924_6400.n59 11.6805
R1920 a_6924_6400.n42 a_6924_6400.n41 11.6805
R1921 a_6924_6400.n43 a_6924_6400.n42 11.6805
R1922 a_6924_6400.n44 a_6924_6400.n43 11.6805
R1923 a_6924_6400.n45 a_6924_6400.n44 11.6805
R1924 a_6924_6400.n46 a_6924_6400.n45 11.6805
R1925 a_6924_6400.n60 a_6924_6400.n46 11.6805
R1926 a_6924_6400.n58 a_6924_6400.n47 11.6805
R1927 a_6924_6400.n54 a_6924_6400.n47 11.6805
R1928 a_6924_6400.n54 a_6924_6400.n53 11.6805
R1929 a_6924_6400.n53 a_6924_6400.n52 11.6805
R1930 a_6924_6400.n52 a_6924_6400.n49 11.6805
R1931 a_6924_6400.n30 a_6924_6400.n29 11.6805
R1932 a_6924_6400.n31 a_6924_6400.n30 11.6805
R1933 a_6924_6400.n13 a_6924_6400.n12 11.6805
R1934 a_6924_6400.n14 a_6924_6400.n13 11.6805
R1935 a_6924_6400.n15 a_6924_6400.n14 11.6805
R1936 a_6924_6400.n16 a_6924_6400.n15 11.6805
R1937 a_6924_6400.n17 a_6924_6400.n16 11.6805
R1938 a_6924_6400.n31 a_6924_6400.n17 11.6805
R1939 a_6924_6400.n29 a_6924_6400.n18 11.6805
R1940 a_6924_6400.n25 a_6924_6400.n18 11.6805
R1941 a_6924_6400.n25 a_6924_6400.n24 11.6805
R1942 a_6924_6400.n24 a_6924_6400.n23 11.6805
R1943 a_6924_6400.n23 a_6924_6400.n20 11.6805
R1944 a_6924_6400.n63 a_6924_6400.n33 10.013
R1945 a_6924_6400.n63 a_6924_6400.n62 9.91657
R1946 a_6924_6400.n51 a_6924_6400.n50 7.17687
R1947 a_6924_6400.n40 a_6924_6400.n39 7.17687
R1948 a_6924_6400.n22 a_6924_6400.n21 7.17687
R1949 a_6924_6400.n11 a_6924_6400.n10 7.17687
R1950 a_6924_6400.n64 a_6924_6400.n4 6.5392
R1951 a_6924_6400.t5 a_6924_6400.n69 5.7796
R1952 a_6924_6400.n1 a_6924_6400.t11 5.73764
R1953 a_6924_6400.n65 a_6924_6400.t0 5.59012
R1954 a_6924_6400.n4 a_6924_6400.t6 5.54817
R1955 a_6924_6400.n69 a_6924_6400.n68 5.38537
R1956 a_6924_6400.n67 a_6924_6400.n66 5.38537
R1957 a_6924_6400.n1 a_6924_6400.n0 5.32067
R1958 a_6924_6400.n3 a_6924_6400.n2 5.32067
R1959 a_6924_6400.n65 a_6924_6400.n64 4.61063
R1960 a_6924_6400.n41 a_6924_6400.n40 4.42851
R1961 a_6924_6400.n50 a_6924_6400.n49 4.42851
R1962 a_6924_6400.n12 a_6924_6400.n11 4.42851
R1963 a_6924_6400.n21 a_6924_6400.n20 4.42851
R1964 a_6924_6400.n0 a_6924_6400.t9 0.228
R1965 a_6924_6400.n0 a_6924_6400.t10 0.228
R1966 a_6924_6400.n2 a_6924_6400.t7 0.228
R1967 a_6924_6400.n2 a_6924_6400.t8 0.228
R1968 a_6924_6400.n68 a_6924_6400.t3 0.20525
R1969 a_6924_6400.n68 a_6924_6400.t4 0.20525
R1970 a_6924_6400.n66 a_6924_6400.t1 0.20525
R1971 a_6924_6400.n66 a_6924_6400.t2 0.20525
R1972 a_6924_6400.n67 a_6924_6400.n65 0.189974
R1973 a_6924_6400.n69 a_6924_6400.n67 0.189974
R1974 a_6924_6400.n4 a_6924_6400.n3 0.189974
R1975 a_6924_6400.n3 a_6924_6400.n1 0.189974
R1976 a_6924_6400.n57 a_6924_6400.n34 0.1205
R1977 a_6924_6400.n57 a_6924_6400.n56 0.1205
R1978 a_6924_6400.n56 a_6924_6400.n55 0.1205
R1979 a_6924_6400.n55 a_6924_6400.n48 0.1205
R1980 a_6924_6400.n51 a_6924_6400.n48 0.1205
R1981 a_6924_6400.n39 a_6924_6400.n38 0.1205
R1982 a_6924_6400.n38 a_6924_6400.n37 0.1205
R1983 a_6924_6400.n37 a_6924_6400.n36 0.1205
R1984 a_6924_6400.n36 a_6924_6400.n35 0.1205
R1985 a_6924_6400.n61 a_6924_6400.n35 0.1205
R1986 a_6924_6400.n28 a_6924_6400.n5 0.1205
R1987 a_6924_6400.n28 a_6924_6400.n27 0.1205
R1988 a_6924_6400.n27 a_6924_6400.n26 0.1205
R1989 a_6924_6400.n26 a_6924_6400.n19 0.1205
R1990 a_6924_6400.n22 a_6924_6400.n19 0.1205
R1991 a_6924_6400.n10 a_6924_6400.n9 0.1205
R1992 a_6924_6400.n9 a_6924_6400.n8 0.1205
R1993 a_6924_6400.n8 a_6924_6400.n7 0.1205
R1994 a_6924_6400.n7 a_6924_6400.n6 0.1205
R1995 a_6924_6400.n32 a_6924_6400.n6 0.1205
R1996 a_6924_6400.n62 a_6924_6400.n34 0.0485
R1997 a_6924_6400.n62 a_6924_6400.n61 0.0485
R1998 a_6924_6400.n33 a_6924_6400.n5 0.0485
R1999 a_6924_6400.n33 a_6924_6400.n32 0.0485
R2000 a_4812_6400.n18 a_4812_6400.t15 113.632
R2001 a_4812_6400.n22 a_4812_6400.t8 113.632
R2002 a_4812_6400.n5 a_4812_6400.t23 113.632
R2003 a_4812_6400.n9 a_4812_6400.t16 113.632
R2004 a_4812_6400.n25 a_4812_6400.t11 109.174
R2005 a_4812_6400.n26 a_4812_6400.t12 109.174
R2006 a_4812_6400.n19 a_4812_6400.t14 109.174
R2007 a_4812_6400.n20 a_4812_6400.t13 109.174
R2008 a_4812_6400.n24 a_4812_6400.t10 109.174
R2009 a_4812_6400.n21 a_4812_6400.t9 109.174
R2010 a_4812_6400.n12 a_4812_6400.t19 109.174
R2011 a_4812_6400.n13 a_4812_6400.t20 109.174
R2012 a_4812_6400.n6 a_4812_6400.t22 109.174
R2013 a_4812_6400.n7 a_4812_6400.t21 109.174
R2014 a_4812_6400.n11 a_4812_6400.t18 109.174
R2015 a_4812_6400.n8 a_4812_6400.t17 109.174
R2016 a_4812_6400.n25 a_4812_6400.n16 18.4942
R2017 a_4812_6400.n27 a_4812_6400.n26 18.4942
R2018 a_4812_6400.n20 a_4812_6400.n17 18.4942
R2019 a_4812_6400.n24 a_4812_6400.n23 18.4942
R2020 a_4812_6400.n12 a_4812_6400.n3 18.4942
R2021 a_4812_6400.n14 a_4812_6400.n13 18.4942
R2022 a_4812_6400.n7 a_4812_6400.n4 18.4942
R2023 a_4812_6400.n11 a_4812_6400.n10 18.4942
R2024 a_4812_6400.n30 a_4812_6400.n29 17.6174
R2025 a_4812_6400.n25 a_4812_6400.n24 11.6805
R2026 a_4812_6400.n26 a_4812_6400.n25 11.6805
R2027 a_4812_6400.n20 a_4812_6400.n19 11.6805
R2028 a_4812_6400.n26 a_4812_6400.n20 11.6805
R2029 a_4812_6400.n24 a_4812_6400.n21 11.6805
R2030 a_4812_6400.n12 a_4812_6400.n11 11.6805
R2031 a_4812_6400.n13 a_4812_6400.n12 11.6805
R2032 a_4812_6400.n7 a_4812_6400.n6 11.6805
R2033 a_4812_6400.n13 a_4812_6400.n7 11.6805
R2034 a_4812_6400.n11 a_4812_6400.n8 11.6805
R2035 a_4812_6400.n29 a_4812_6400.n15 10.3505
R2036 a_4812_6400.n29 a_4812_6400.n28 9.57907
R2037 a_4812_6400.n23 a_4812_6400.n22 7.17687
R2038 a_4812_6400.n18 a_4812_6400.n17 7.17687
R2039 a_4812_6400.n10 a_4812_6400.n9 7.17687
R2040 a_4812_6400.n5 a_4812_6400.n4 7.17687
R2041 a_4812_6400.n30 a_4812_6400.n2 6.5392
R2042 a_4812_6400.t3 a_4812_6400.n33 5.7796
R2043 a_4812_6400.n1 a_4812_6400.t7 5.73764
R2044 a_4812_6400.n31 a_4812_6400.t0 5.59012
R2045 a_4812_6400.n2 a_4812_6400.t4 5.54817
R2046 a_4812_6400.n33 a_4812_6400.n32 5.38537
R2047 a_4812_6400.n1 a_4812_6400.n0 5.32067
R2048 a_4812_6400.n31 a_4812_6400.n30 4.61063
R2049 a_4812_6400.n19 a_4812_6400.n18 4.42851
R2050 a_4812_6400.n22 a_4812_6400.n21 4.42851
R2051 a_4812_6400.n6 a_4812_6400.n5 4.42851
R2052 a_4812_6400.n9 a_4812_6400.n8 4.42851
R2053 a_4812_6400.n0 a_4812_6400.t5 0.228
R2054 a_4812_6400.n0 a_4812_6400.t6 0.228
R2055 a_4812_6400.n32 a_4812_6400.t1 0.20525
R2056 a_4812_6400.n32 a_4812_6400.t2 0.20525
R2057 a_4812_6400.n33 a_4812_6400.n31 0.189974
R2058 a_4812_6400.n2 a_4812_6400.n1 0.189974
R2059 a_4812_6400.n23 a_4812_6400.n16 0.1205
R2060 a_4812_6400.n27 a_4812_6400.n17 0.1205
R2061 a_4812_6400.n10 a_4812_6400.n3 0.1205
R2062 a_4812_6400.n14 a_4812_6400.n4 0.1205
R2063 a_4812_6400.n28 a_4812_6400.n16 0.0485
R2064 a_4812_6400.n28 a_4812_6400.n27 0.0485
R2065 a_4812_6400.n15 a_4812_6400.n3 0.0485
R2066 a_4812_6400.n15 a_4812_6400.n14 0.0485
R2067 a_2700_6400.n18 a_2700_6400.t15 113.632
R2068 a_2700_6400.n22 a_2700_6400.t8 113.632
R2069 a_2700_6400.n5 a_2700_6400.t23 113.632
R2070 a_2700_6400.n9 a_2700_6400.t16 113.632
R2071 a_2700_6400.n25 a_2700_6400.t11 109.174
R2072 a_2700_6400.n26 a_2700_6400.t12 109.174
R2073 a_2700_6400.n19 a_2700_6400.t14 109.174
R2074 a_2700_6400.n20 a_2700_6400.t13 109.174
R2075 a_2700_6400.n24 a_2700_6400.t10 109.174
R2076 a_2700_6400.n21 a_2700_6400.t9 109.174
R2077 a_2700_6400.n12 a_2700_6400.t19 109.174
R2078 a_2700_6400.n13 a_2700_6400.t20 109.174
R2079 a_2700_6400.n6 a_2700_6400.t22 109.174
R2080 a_2700_6400.n7 a_2700_6400.t21 109.174
R2081 a_2700_6400.n11 a_2700_6400.t18 109.174
R2082 a_2700_6400.n8 a_2700_6400.t17 109.174
R2083 a_2700_6400.n25 a_2700_6400.n16 18.4942
R2084 a_2700_6400.n27 a_2700_6400.n26 18.4942
R2085 a_2700_6400.n20 a_2700_6400.n17 18.4942
R2086 a_2700_6400.n24 a_2700_6400.n23 18.4942
R2087 a_2700_6400.n12 a_2700_6400.n3 18.4942
R2088 a_2700_6400.n14 a_2700_6400.n13 18.4942
R2089 a_2700_6400.n7 a_2700_6400.n4 18.4942
R2090 a_2700_6400.n11 a_2700_6400.n10 18.4942
R2091 a_2700_6400.n30 a_2700_6400.n29 17.3289
R2092 a_2700_6400.n25 a_2700_6400.n24 11.6805
R2093 a_2700_6400.n26 a_2700_6400.n25 11.6805
R2094 a_2700_6400.n20 a_2700_6400.n19 11.6805
R2095 a_2700_6400.n26 a_2700_6400.n20 11.6805
R2096 a_2700_6400.n24 a_2700_6400.n21 11.6805
R2097 a_2700_6400.n12 a_2700_6400.n11 11.6805
R2098 a_2700_6400.n13 a_2700_6400.n12 11.6805
R2099 a_2700_6400.n7 a_2700_6400.n6 11.6805
R2100 a_2700_6400.n13 a_2700_6400.n7 11.6805
R2101 a_2700_6400.n11 a_2700_6400.n8 11.6805
R2102 a_2700_6400.n29 a_2700_6400.n15 10.688
R2103 a_2700_6400.n29 a_2700_6400.n28 9.24157
R2104 a_2700_6400.n23 a_2700_6400.n22 7.17687
R2105 a_2700_6400.n18 a_2700_6400.n17 7.17687
R2106 a_2700_6400.n10 a_2700_6400.n9 7.17687
R2107 a_2700_6400.n5 a_2700_6400.n4 7.17687
R2108 a_2700_6400.n30 a_2700_6400.n2 6.5392
R2109 a_2700_6400.t3 a_2700_6400.n33 5.7796
R2110 a_2700_6400.n1 a_2700_6400.t7 5.73764
R2111 a_2700_6400.n31 a_2700_6400.t0 5.59012
R2112 a_2700_6400.n2 a_2700_6400.t4 5.54817
R2113 a_2700_6400.n33 a_2700_6400.n32 5.38537
R2114 a_2700_6400.n1 a_2700_6400.n0 5.32067
R2115 a_2700_6400.n31 a_2700_6400.n30 4.61063
R2116 a_2700_6400.n19 a_2700_6400.n18 4.42851
R2117 a_2700_6400.n22 a_2700_6400.n21 4.42851
R2118 a_2700_6400.n6 a_2700_6400.n5 4.42851
R2119 a_2700_6400.n9 a_2700_6400.n8 4.42851
R2120 a_2700_6400.n0 a_2700_6400.t5 0.228
R2121 a_2700_6400.n0 a_2700_6400.t6 0.228
R2122 a_2700_6400.n32 a_2700_6400.t1 0.20525
R2123 a_2700_6400.n32 a_2700_6400.t2 0.20525
R2124 a_2700_6400.n33 a_2700_6400.n31 0.189974
R2125 a_2700_6400.n2 a_2700_6400.n1 0.189974
R2126 a_2700_6400.n23 a_2700_6400.n16 0.1205
R2127 a_2700_6400.n27 a_2700_6400.n17 0.1205
R2128 a_2700_6400.n10 a_2700_6400.n3 0.1205
R2129 a_2700_6400.n14 a_2700_6400.n4 0.1205
R2130 a_2700_6400.n28 a_2700_6400.n16 0.0485
R2131 a_2700_6400.n28 a_2700_6400.n27 0.0485
R2132 a_2700_6400.n15 a_2700_6400.n3 0.0485
R2133 a_2700_6400.n15 a_2700_6400.n14 0.0485
R2134 a_14860_41600.n100 a_14860_41600.t63 113.632
R2135 a_14860_41600.n122 a_14860_41600.t32 113.632
R2136 a_14860_41600.n39 a_14860_41600.t95 113.632
R2137 a_14860_41600.n61 a_14860_41600.t64 113.632
R2138 a_14860_41600.n143 a_14860_41600.t47 109.174
R2139 a_14860_41600.n144 a_14860_41600.t48 109.174
R2140 a_14860_41600.n101 a_14860_41600.t62 109.174
R2141 a_14860_41600.n102 a_14860_41600.t61 109.174
R2142 a_14860_41600.n103 a_14860_41600.t60 109.174
R2143 a_14860_41600.n104 a_14860_41600.t59 109.174
R2144 a_14860_41600.n105 a_14860_41600.t58 109.174
R2145 a_14860_41600.n106 a_14860_41600.t57 109.174
R2146 a_14860_41600.n107 a_14860_41600.t56 109.174
R2147 a_14860_41600.n108 a_14860_41600.t55 109.174
R2148 a_14860_41600.n109 a_14860_41600.t54 109.174
R2149 a_14860_41600.n110 a_14860_41600.t53 109.174
R2150 a_14860_41600.n111 a_14860_41600.t52 109.174
R2151 a_14860_41600.n112 a_14860_41600.t51 109.174
R2152 a_14860_41600.n113 a_14860_41600.t50 109.174
R2153 a_14860_41600.n114 a_14860_41600.t49 109.174
R2154 a_14860_41600.n142 a_14860_41600.t46 109.174
R2155 a_14860_41600.n115 a_14860_41600.t45 109.174
R2156 a_14860_41600.n138 a_14860_41600.t44 109.174
R2157 a_14860_41600.n137 a_14860_41600.t43 109.174
R2158 a_14860_41600.n136 a_14860_41600.t42 109.174
R2159 a_14860_41600.n117 a_14860_41600.t41 109.174
R2160 a_14860_41600.n132 a_14860_41600.t40 109.174
R2161 a_14860_41600.n131 a_14860_41600.t39 109.174
R2162 a_14860_41600.n130 a_14860_41600.t38 109.174
R2163 a_14860_41600.n119 a_14860_41600.t37 109.174
R2164 a_14860_41600.n126 a_14860_41600.t36 109.174
R2165 a_14860_41600.n125 a_14860_41600.t35 109.174
R2166 a_14860_41600.n124 a_14860_41600.t34 109.174
R2167 a_14860_41600.n121 a_14860_41600.t33 109.174
R2168 a_14860_41600.n82 a_14860_41600.t79 109.174
R2169 a_14860_41600.n83 a_14860_41600.t80 109.174
R2170 a_14860_41600.n40 a_14860_41600.t94 109.174
R2171 a_14860_41600.n41 a_14860_41600.t93 109.174
R2172 a_14860_41600.n42 a_14860_41600.t92 109.174
R2173 a_14860_41600.n43 a_14860_41600.t91 109.174
R2174 a_14860_41600.n44 a_14860_41600.t90 109.174
R2175 a_14860_41600.n45 a_14860_41600.t89 109.174
R2176 a_14860_41600.n46 a_14860_41600.t88 109.174
R2177 a_14860_41600.n47 a_14860_41600.t87 109.174
R2178 a_14860_41600.n48 a_14860_41600.t86 109.174
R2179 a_14860_41600.n49 a_14860_41600.t85 109.174
R2180 a_14860_41600.n50 a_14860_41600.t84 109.174
R2181 a_14860_41600.n51 a_14860_41600.t83 109.174
R2182 a_14860_41600.n52 a_14860_41600.t82 109.174
R2183 a_14860_41600.n53 a_14860_41600.t81 109.174
R2184 a_14860_41600.n81 a_14860_41600.t78 109.174
R2185 a_14860_41600.n54 a_14860_41600.t77 109.174
R2186 a_14860_41600.n77 a_14860_41600.t76 109.174
R2187 a_14860_41600.n76 a_14860_41600.t75 109.174
R2188 a_14860_41600.n75 a_14860_41600.t74 109.174
R2189 a_14860_41600.n56 a_14860_41600.t73 109.174
R2190 a_14860_41600.n71 a_14860_41600.t72 109.174
R2191 a_14860_41600.n70 a_14860_41600.t71 109.174
R2192 a_14860_41600.n69 a_14860_41600.t70 109.174
R2193 a_14860_41600.n58 a_14860_41600.t69 109.174
R2194 a_14860_41600.n65 a_14860_41600.t68 109.174
R2195 a_14860_41600.n64 a_14860_41600.t67 109.174
R2196 a_14860_41600.n63 a_14860_41600.t66 109.174
R2197 a_14860_41600.n60 a_14860_41600.t65 109.174
R2198 a_14860_41600.n143 a_14860_41600.n86 18.4942
R2199 a_14860_41600.n145 a_14860_41600.n144 18.4942
R2200 a_14860_41600.n102 a_14860_41600.n99 18.4942
R2201 a_14860_41600.n103 a_14860_41600.n98 18.4942
R2202 a_14860_41600.n104 a_14860_41600.n97 18.4942
R2203 a_14860_41600.n105 a_14860_41600.n96 18.4942
R2204 a_14860_41600.n106 a_14860_41600.n95 18.4942
R2205 a_14860_41600.n107 a_14860_41600.n94 18.4942
R2206 a_14860_41600.n108 a_14860_41600.n93 18.4942
R2207 a_14860_41600.n109 a_14860_41600.n92 18.4942
R2208 a_14860_41600.n110 a_14860_41600.n91 18.4942
R2209 a_14860_41600.n111 a_14860_41600.n90 18.4942
R2210 a_14860_41600.n112 a_14860_41600.n89 18.4942
R2211 a_14860_41600.n113 a_14860_41600.n88 18.4942
R2212 a_14860_41600.n114 a_14860_41600.n87 18.4942
R2213 a_14860_41600.n142 a_14860_41600.n141 18.4942
R2214 a_14860_41600.n140 a_14860_41600.n115 18.4942
R2215 a_14860_41600.n139 a_14860_41600.n138 18.4942
R2216 a_14860_41600.n137 a_14860_41600.n116 18.4942
R2217 a_14860_41600.n136 a_14860_41600.n135 18.4942
R2218 a_14860_41600.n134 a_14860_41600.n117 18.4942
R2219 a_14860_41600.n133 a_14860_41600.n132 18.4942
R2220 a_14860_41600.n131 a_14860_41600.n118 18.4942
R2221 a_14860_41600.n130 a_14860_41600.n129 18.4942
R2222 a_14860_41600.n128 a_14860_41600.n119 18.4942
R2223 a_14860_41600.n127 a_14860_41600.n126 18.4942
R2224 a_14860_41600.n125 a_14860_41600.n120 18.4942
R2225 a_14860_41600.n124 a_14860_41600.n123 18.4942
R2226 a_14860_41600.n82 a_14860_41600.n25 18.4942
R2227 a_14860_41600.n84 a_14860_41600.n83 18.4942
R2228 a_14860_41600.n41 a_14860_41600.n38 18.4942
R2229 a_14860_41600.n42 a_14860_41600.n37 18.4942
R2230 a_14860_41600.n43 a_14860_41600.n36 18.4942
R2231 a_14860_41600.n44 a_14860_41600.n35 18.4942
R2232 a_14860_41600.n45 a_14860_41600.n34 18.4942
R2233 a_14860_41600.n46 a_14860_41600.n33 18.4942
R2234 a_14860_41600.n47 a_14860_41600.n32 18.4942
R2235 a_14860_41600.n48 a_14860_41600.n31 18.4942
R2236 a_14860_41600.n49 a_14860_41600.n30 18.4942
R2237 a_14860_41600.n50 a_14860_41600.n29 18.4942
R2238 a_14860_41600.n51 a_14860_41600.n28 18.4942
R2239 a_14860_41600.n52 a_14860_41600.n27 18.4942
R2240 a_14860_41600.n53 a_14860_41600.n26 18.4942
R2241 a_14860_41600.n81 a_14860_41600.n80 18.4942
R2242 a_14860_41600.n79 a_14860_41600.n54 18.4942
R2243 a_14860_41600.n78 a_14860_41600.n77 18.4942
R2244 a_14860_41600.n76 a_14860_41600.n55 18.4942
R2245 a_14860_41600.n75 a_14860_41600.n74 18.4942
R2246 a_14860_41600.n73 a_14860_41600.n56 18.4942
R2247 a_14860_41600.n72 a_14860_41600.n71 18.4942
R2248 a_14860_41600.n70 a_14860_41600.n57 18.4942
R2249 a_14860_41600.n69 a_14860_41600.n68 18.4942
R2250 a_14860_41600.n67 a_14860_41600.n58 18.4942
R2251 a_14860_41600.n66 a_14860_41600.n65 18.4942
R2252 a_14860_41600.n64 a_14860_41600.n59 18.4942
R2253 a_14860_41600.n63 a_14860_41600.n62 18.4942
R2254 a_14860_41600.n148 a_14860_41600.n147 16.6402
R2255 a_14860_41600.n143 a_14860_41600.n142 11.6805
R2256 a_14860_41600.n144 a_14860_41600.n143 11.6805
R2257 a_14860_41600.n102 a_14860_41600.n101 11.6805
R2258 a_14860_41600.n103 a_14860_41600.n102 11.6805
R2259 a_14860_41600.n104 a_14860_41600.n103 11.6805
R2260 a_14860_41600.n105 a_14860_41600.n104 11.6805
R2261 a_14860_41600.n106 a_14860_41600.n105 11.6805
R2262 a_14860_41600.n107 a_14860_41600.n106 11.6805
R2263 a_14860_41600.n108 a_14860_41600.n107 11.6805
R2264 a_14860_41600.n109 a_14860_41600.n108 11.6805
R2265 a_14860_41600.n110 a_14860_41600.n109 11.6805
R2266 a_14860_41600.n111 a_14860_41600.n110 11.6805
R2267 a_14860_41600.n112 a_14860_41600.n111 11.6805
R2268 a_14860_41600.n113 a_14860_41600.n112 11.6805
R2269 a_14860_41600.n114 a_14860_41600.n113 11.6805
R2270 a_14860_41600.n144 a_14860_41600.n114 11.6805
R2271 a_14860_41600.n142 a_14860_41600.n115 11.6805
R2272 a_14860_41600.n138 a_14860_41600.n115 11.6805
R2273 a_14860_41600.n138 a_14860_41600.n137 11.6805
R2274 a_14860_41600.n137 a_14860_41600.n136 11.6805
R2275 a_14860_41600.n136 a_14860_41600.n117 11.6805
R2276 a_14860_41600.n132 a_14860_41600.n117 11.6805
R2277 a_14860_41600.n132 a_14860_41600.n131 11.6805
R2278 a_14860_41600.n131 a_14860_41600.n130 11.6805
R2279 a_14860_41600.n130 a_14860_41600.n119 11.6805
R2280 a_14860_41600.n126 a_14860_41600.n119 11.6805
R2281 a_14860_41600.n126 a_14860_41600.n125 11.6805
R2282 a_14860_41600.n125 a_14860_41600.n124 11.6805
R2283 a_14860_41600.n124 a_14860_41600.n121 11.6805
R2284 a_14860_41600.n82 a_14860_41600.n81 11.6805
R2285 a_14860_41600.n83 a_14860_41600.n82 11.6805
R2286 a_14860_41600.n41 a_14860_41600.n40 11.6805
R2287 a_14860_41600.n42 a_14860_41600.n41 11.6805
R2288 a_14860_41600.n43 a_14860_41600.n42 11.6805
R2289 a_14860_41600.n44 a_14860_41600.n43 11.6805
R2290 a_14860_41600.n45 a_14860_41600.n44 11.6805
R2291 a_14860_41600.n46 a_14860_41600.n45 11.6805
R2292 a_14860_41600.n47 a_14860_41600.n46 11.6805
R2293 a_14860_41600.n48 a_14860_41600.n47 11.6805
R2294 a_14860_41600.n49 a_14860_41600.n48 11.6805
R2295 a_14860_41600.n50 a_14860_41600.n49 11.6805
R2296 a_14860_41600.n51 a_14860_41600.n50 11.6805
R2297 a_14860_41600.n52 a_14860_41600.n51 11.6805
R2298 a_14860_41600.n53 a_14860_41600.n52 11.6805
R2299 a_14860_41600.n83 a_14860_41600.n53 11.6805
R2300 a_14860_41600.n81 a_14860_41600.n54 11.6805
R2301 a_14860_41600.n77 a_14860_41600.n54 11.6805
R2302 a_14860_41600.n77 a_14860_41600.n76 11.6805
R2303 a_14860_41600.n76 a_14860_41600.n75 11.6805
R2304 a_14860_41600.n75 a_14860_41600.n56 11.6805
R2305 a_14860_41600.n71 a_14860_41600.n56 11.6805
R2306 a_14860_41600.n71 a_14860_41600.n70 11.6805
R2307 a_14860_41600.n70 a_14860_41600.n69 11.6805
R2308 a_14860_41600.n69 a_14860_41600.n58 11.6805
R2309 a_14860_41600.n65 a_14860_41600.n58 11.6805
R2310 a_14860_41600.n65 a_14860_41600.n64 11.6805
R2311 a_14860_41600.n64 a_14860_41600.n63 11.6805
R2312 a_14860_41600.n63 a_14860_41600.n60 11.6805
R2313 a_14860_41600.n147 a_14860_41600.n85 10.688
R2314 a_14860_41600.n147 a_14860_41600.n146 9.24157
R2315 a_14860_41600.n123 a_14860_41600.n122 7.17687
R2316 a_14860_41600.n100 a_14860_41600.n99 7.17687
R2317 a_14860_41600.n62 a_14860_41600.n61 7.17687
R2318 a_14860_41600.n39 a_14860_41600.n38 7.17687
R2319 a_14860_41600.n148 a_14860_41600.n24 6.5392
R2320 a_14860_41600.n1 a_14860_41600.t21 5.7796
R2321 a_14860_41600.n11 a_14860_41600.t20 5.73764
R2322 a_14860_41600.n149 a_14860_41600.t19 5.59012
R2323 a_14860_41600.n24 a_14860_41600.t10 5.54817
R2324 a_14860_41600.n153 a_14860_41600.n152 5.38537
R2325 a_14860_41600.n1 a_14860_41600.n0 5.38537
R2326 a_14860_41600.n3 a_14860_41600.n2 5.38537
R2327 a_14860_41600.n5 a_14860_41600.n4 5.38537
R2328 a_14860_41600.n7 a_14860_41600.n6 5.38537
R2329 a_14860_41600.n9 a_14860_41600.n8 5.38537
R2330 a_14860_41600.n151 a_14860_41600.n150 5.38537
R2331 a_14860_41600.n11 a_14860_41600.n10 5.32067
R2332 a_14860_41600.n13 a_14860_41600.n12 5.32067
R2333 a_14860_41600.n15 a_14860_41600.n14 5.32067
R2334 a_14860_41600.n17 a_14860_41600.n16 5.32067
R2335 a_14860_41600.n19 a_14860_41600.n18 5.32067
R2336 a_14860_41600.n21 a_14860_41600.n20 5.32067
R2337 a_14860_41600.n23 a_14860_41600.n22 5.32067
R2338 a_14860_41600.n149 a_14860_41600.n148 4.61063
R2339 a_14860_41600.n101 a_14860_41600.n100 4.42851
R2340 a_14860_41600.n122 a_14860_41600.n121 4.42851
R2341 a_14860_41600.n40 a_14860_41600.n39 4.42851
R2342 a_14860_41600.n61 a_14860_41600.n60 4.42851
R2343 a_14860_41600.n10 a_14860_41600.t12 0.228
R2344 a_14860_41600.n10 a_14860_41600.t11 0.228
R2345 a_14860_41600.n12 a_14860_41600.t5 0.228
R2346 a_14860_41600.n12 a_14860_41600.t4 0.228
R2347 a_14860_41600.n14 a_14860_41600.t29 0.228
R2348 a_14860_41600.n14 a_14860_41600.t28 0.228
R2349 a_14860_41600.n16 a_14860_41600.t16 0.228
R2350 a_14860_41600.n16 a_14860_41600.t15 0.228
R2351 a_14860_41600.n18 a_14860_41600.t14 0.228
R2352 a_14860_41600.n18 a_14860_41600.t13 0.228
R2353 a_14860_41600.n20 a_14860_41600.t25 0.228
R2354 a_14860_41600.n20 a_14860_41600.t24 0.228
R2355 a_14860_41600.n22 a_14860_41600.t18 0.228
R2356 a_14860_41600.n22 a_14860_41600.t17 0.228
R2357 a_14860_41600.n153 a_14860_41600.t1 0.20525
R2358 a_14860_41600.t0 a_14860_41600.n153 0.20525
R2359 a_14860_41600.n0 a_14860_41600.t9 0.20525
R2360 a_14860_41600.n0 a_14860_41600.t8 0.20525
R2361 a_14860_41600.n2 a_14860_41600.t27 0.20525
R2362 a_14860_41600.n2 a_14860_41600.t26 0.20525
R2363 a_14860_41600.n4 a_14860_41600.t7 0.20525
R2364 a_14860_41600.n4 a_14860_41600.t6 0.20525
R2365 a_14860_41600.n6 a_14860_41600.t31 0.20525
R2366 a_14860_41600.n6 a_14860_41600.t30 0.20525
R2367 a_14860_41600.n8 a_14860_41600.t3 0.20525
R2368 a_14860_41600.n8 a_14860_41600.t2 0.20525
R2369 a_14860_41600.n150 a_14860_41600.t23 0.20525
R2370 a_14860_41600.n150 a_14860_41600.t22 0.20525
R2371 a_14860_41600.n151 a_14860_41600.n149 0.189974
R2372 a_14860_41600.n152 a_14860_41600.n151 0.189974
R2373 a_14860_41600.n152 a_14860_41600.n9 0.189974
R2374 a_14860_41600.n9 a_14860_41600.n7 0.189974
R2375 a_14860_41600.n7 a_14860_41600.n5 0.189974
R2376 a_14860_41600.n5 a_14860_41600.n3 0.189974
R2377 a_14860_41600.n3 a_14860_41600.n1 0.189974
R2378 a_14860_41600.n24 a_14860_41600.n23 0.189974
R2379 a_14860_41600.n23 a_14860_41600.n21 0.189974
R2380 a_14860_41600.n21 a_14860_41600.n19 0.189974
R2381 a_14860_41600.n19 a_14860_41600.n17 0.189974
R2382 a_14860_41600.n17 a_14860_41600.n15 0.189974
R2383 a_14860_41600.n15 a_14860_41600.n13 0.189974
R2384 a_14860_41600.n13 a_14860_41600.n11 0.189974
R2385 a_14860_41600.n141 a_14860_41600.n86 0.1205
R2386 a_14860_41600.n141 a_14860_41600.n140 0.1205
R2387 a_14860_41600.n140 a_14860_41600.n139 0.1205
R2388 a_14860_41600.n139 a_14860_41600.n116 0.1205
R2389 a_14860_41600.n135 a_14860_41600.n116 0.1205
R2390 a_14860_41600.n135 a_14860_41600.n134 0.1205
R2391 a_14860_41600.n134 a_14860_41600.n133 0.1205
R2392 a_14860_41600.n133 a_14860_41600.n118 0.1205
R2393 a_14860_41600.n129 a_14860_41600.n118 0.1205
R2394 a_14860_41600.n129 a_14860_41600.n128 0.1205
R2395 a_14860_41600.n128 a_14860_41600.n127 0.1205
R2396 a_14860_41600.n127 a_14860_41600.n120 0.1205
R2397 a_14860_41600.n123 a_14860_41600.n120 0.1205
R2398 a_14860_41600.n99 a_14860_41600.n98 0.1205
R2399 a_14860_41600.n98 a_14860_41600.n97 0.1205
R2400 a_14860_41600.n97 a_14860_41600.n96 0.1205
R2401 a_14860_41600.n96 a_14860_41600.n95 0.1205
R2402 a_14860_41600.n95 a_14860_41600.n94 0.1205
R2403 a_14860_41600.n94 a_14860_41600.n93 0.1205
R2404 a_14860_41600.n93 a_14860_41600.n92 0.1205
R2405 a_14860_41600.n92 a_14860_41600.n91 0.1205
R2406 a_14860_41600.n91 a_14860_41600.n90 0.1205
R2407 a_14860_41600.n90 a_14860_41600.n89 0.1205
R2408 a_14860_41600.n89 a_14860_41600.n88 0.1205
R2409 a_14860_41600.n88 a_14860_41600.n87 0.1205
R2410 a_14860_41600.n145 a_14860_41600.n87 0.1205
R2411 a_14860_41600.n80 a_14860_41600.n25 0.1205
R2412 a_14860_41600.n80 a_14860_41600.n79 0.1205
R2413 a_14860_41600.n79 a_14860_41600.n78 0.1205
R2414 a_14860_41600.n78 a_14860_41600.n55 0.1205
R2415 a_14860_41600.n74 a_14860_41600.n55 0.1205
R2416 a_14860_41600.n74 a_14860_41600.n73 0.1205
R2417 a_14860_41600.n73 a_14860_41600.n72 0.1205
R2418 a_14860_41600.n72 a_14860_41600.n57 0.1205
R2419 a_14860_41600.n68 a_14860_41600.n57 0.1205
R2420 a_14860_41600.n68 a_14860_41600.n67 0.1205
R2421 a_14860_41600.n67 a_14860_41600.n66 0.1205
R2422 a_14860_41600.n66 a_14860_41600.n59 0.1205
R2423 a_14860_41600.n62 a_14860_41600.n59 0.1205
R2424 a_14860_41600.n38 a_14860_41600.n37 0.1205
R2425 a_14860_41600.n37 a_14860_41600.n36 0.1205
R2426 a_14860_41600.n36 a_14860_41600.n35 0.1205
R2427 a_14860_41600.n35 a_14860_41600.n34 0.1205
R2428 a_14860_41600.n34 a_14860_41600.n33 0.1205
R2429 a_14860_41600.n33 a_14860_41600.n32 0.1205
R2430 a_14860_41600.n32 a_14860_41600.n31 0.1205
R2431 a_14860_41600.n31 a_14860_41600.n30 0.1205
R2432 a_14860_41600.n30 a_14860_41600.n29 0.1205
R2433 a_14860_41600.n29 a_14860_41600.n28 0.1205
R2434 a_14860_41600.n28 a_14860_41600.n27 0.1205
R2435 a_14860_41600.n27 a_14860_41600.n26 0.1205
R2436 a_14860_41600.n84 a_14860_41600.n26 0.1205
R2437 a_14860_41600.n146 a_14860_41600.n86 0.0485
R2438 a_14860_41600.n146 a_14860_41600.n145 0.0485
R2439 a_14860_41600.n85 a_14860_41600.n25 0.0485
R2440 a_14860_41600.n85 a_14860_41600.n84 0.0485
R2441 a_6924_41600.n40 a_6924_41600.t27 113.632
R2442 a_6924_41600.n50 a_6924_41600.t12 113.632
R2443 a_6924_41600.n11 a_6924_41600.t43 113.632
R2444 a_6924_41600.n21 a_6924_41600.t28 113.632
R2445 a_6924_41600.n59 a_6924_41600.t19 109.174
R2446 a_6924_41600.n60 a_6924_41600.t20 109.174
R2447 a_6924_41600.n41 a_6924_41600.t26 109.174
R2448 a_6924_41600.n42 a_6924_41600.t25 109.174
R2449 a_6924_41600.n43 a_6924_41600.t24 109.174
R2450 a_6924_41600.n44 a_6924_41600.t23 109.174
R2451 a_6924_41600.n45 a_6924_41600.t22 109.174
R2452 a_6924_41600.n46 a_6924_41600.t21 109.174
R2453 a_6924_41600.n58 a_6924_41600.t18 109.174
R2454 a_6924_41600.n47 a_6924_41600.t17 109.174
R2455 a_6924_41600.n54 a_6924_41600.t16 109.174
R2456 a_6924_41600.n53 a_6924_41600.t15 109.174
R2457 a_6924_41600.n52 a_6924_41600.t14 109.174
R2458 a_6924_41600.n49 a_6924_41600.t13 109.174
R2459 a_6924_41600.n30 a_6924_41600.t35 109.174
R2460 a_6924_41600.n31 a_6924_41600.t36 109.174
R2461 a_6924_41600.n12 a_6924_41600.t42 109.174
R2462 a_6924_41600.n13 a_6924_41600.t41 109.174
R2463 a_6924_41600.n14 a_6924_41600.t40 109.174
R2464 a_6924_41600.n15 a_6924_41600.t39 109.174
R2465 a_6924_41600.n16 a_6924_41600.t38 109.174
R2466 a_6924_41600.n17 a_6924_41600.t37 109.174
R2467 a_6924_41600.n29 a_6924_41600.t34 109.174
R2468 a_6924_41600.n18 a_6924_41600.t33 109.174
R2469 a_6924_41600.n25 a_6924_41600.t32 109.174
R2470 a_6924_41600.n24 a_6924_41600.t31 109.174
R2471 a_6924_41600.n23 a_6924_41600.t30 109.174
R2472 a_6924_41600.n20 a_6924_41600.t29 109.174
R2473 a_6924_41600.n64 a_6924_41600.n63 18.5321
R2474 a_6924_41600.n59 a_6924_41600.n34 18.4942
R2475 a_6924_41600.n61 a_6924_41600.n60 18.4942
R2476 a_6924_41600.n42 a_6924_41600.n39 18.4942
R2477 a_6924_41600.n43 a_6924_41600.n38 18.4942
R2478 a_6924_41600.n44 a_6924_41600.n37 18.4942
R2479 a_6924_41600.n45 a_6924_41600.n36 18.4942
R2480 a_6924_41600.n46 a_6924_41600.n35 18.4942
R2481 a_6924_41600.n58 a_6924_41600.n57 18.4942
R2482 a_6924_41600.n56 a_6924_41600.n47 18.4942
R2483 a_6924_41600.n55 a_6924_41600.n54 18.4942
R2484 a_6924_41600.n53 a_6924_41600.n48 18.4942
R2485 a_6924_41600.n52 a_6924_41600.n51 18.4942
R2486 a_6924_41600.n30 a_6924_41600.n5 18.4942
R2487 a_6924_41600.n32 a_6924_41600.n31 18.4942
R2488 a_6924_41600.n13 a_6924_41600.n10 18.4942
R2489 a_6924_41600.n14 a_6924_41600.n9 18.4942
R2490 a_6924_41600.n15 a_6924_41600.n8 18.4942
R2491 a_6924_41600.n16 a_6924_41600.n7 18.4942
R2492 a_6924_41600.n17 a_6924_41600.n6 18.4942
R2493 a_6924_41600.n29 a_6924_41600.n28 18.4942
R2494 a_6924_41600.n27 a_6924_41600.n18 18.4942
R2495 a_6924_41600.n26 a_6924_41600.n25 18.4942
R2496 a_6924_41600.n24 a_6924_41600.n19 18.4942
R2497 a_6924_41600.n23 a_6924_41600.n22 18.4942
R2498 a_6924_41600.n59 a_6924_41600.n58 11.6805
R2499 a_6924_41600.n60 a_6924_41600.n59 11.6805
R2500 a_6924_41600.n42 a_6924_41600.n41 11.6805
R2501 a_6924_41600.n43 a_6924_41600.n42 11.6805
R2502 a_6924_41600.n44 a_6924_41600.n43 11.6805
R2503 a_6924_41600.n45 a_6924_41600.n44 11.6805
R2504 a_6924_41600.n46 a_6924_41600.n45 11.6805
R2505 a_6924_41600.n60 a_6924_41600.n46 11.6805
R2506 a_6924_41600.n58 a_6924_41600.n47 11.6805
R2507 a_6924_41600.n54 a_6924_41600.n47 11.6805
R2508 a_6924_41600.n54 a_6924_41600.n53 11.6805
R2509 a_6924_41600.n53 a_6924_41600.n52 11.6805
R2510 a_6924_41600.n52 a_6924_41600.n49 11.6805
R2511 a_6924_41600.n30 a_6924_41600.n29 11.6805
R2512 a_6924_41600.n31 a_6924_41600.n30 11.6805
R2513 a_6924_41600.n13 a_6924_41600.n12 11.6805
R2514 a_6924_41600.n14 a_6924_41600.n13 11.6805
R2515 a_6924_41600.n15 a_6924_41600.n14 11.6805
R2516 a_6924_41600.n16 a_6924_41600.n15 11.6805
R2517 a_6924_41600.n17 a_6924_41600.n16 11.6805
R2518 a_6924_41600.n31 a_6924_41600.n17 11.6805
R2519 a_6924_41600.n29 a_6924_41600.n18 11.6805
R2520 a_6924_41600.n25 a_6924_41600.n18 11.6805
R2521 a_6924_41600.n25 a_6924_41600.n24 11.6805
R2522 a_6924_41600.n24 a_6924_41600.n23 11.6805
R2523 a_6924_41600.n23 a_6924_41600.n20 11.6805
R2524 a_6924_41600.n63 a_6924_41600.n33 10.013
R2525 a_6924_41600.n63 a_6924_41600.n62 9.91657
R2526 a_6924_41600.n51 a_6924_41600.n50 7.17687
R2527 a_6924_41600.n40 a_6924_41600.n39 7.17687
R2528 a_6924_41600.n22 a_6924_41600.n21 7.17687
R2529 a_6924_41600.n11 a_6924_41600.n10 7.17687
R2530 a_6924_41600.n64 a_6924_41600.n4 6.5392
R2531 a_6924_41600.t5 a_6924_41600.n69 5.7796
R2532 a_6924_41600.n1 a_6924_41600.t11 5.73764
R2533 a_6924_41600.n65 a_6924_41600.t0 5.59012
R2534 a_6924_41600.n4 a_6924_41600.t6 5.54817
R2535 a_6924_41600.n69 a_6924_41600.n68 5.38537
R2536 a_6924_41600.n67 a_6924_41600.n66 5.38537
R2537 a_6924_41600.n1 a_6924_41600.n0 5.32067
R2538 a_6924_41600.n3 a_6924_41600.n2 5.32067
R2539 a_6924_41600.n65 a_6924_41600.n64 4.61063
R2540 a_6924_41600.n41 a_6924_41600.n40 4.42851
R2541 a_6924_41600.n50 a_6924_41600.n49 4.42851
R2542 a_6924_41600.n12 a_6924_41600.n11 4.42851
R2543 a_6924_41600.n21 a_6924_41600.n20 4.42851
R2544 a_6924_41600.n0 a_6924_41600.t9 0.228
R2545 a_6924_41600.n0 a_6924_41600.t10 0.228
R2546 a_6924_41600.n2 a_6924_41600.t7 0.228
R2547 a_6924_41600.n2 a_6924_41600.t8 0.228
R2548 a_6924_41600.n68 a_6924_41600.t3 0.20525
R2549 a_6924_41600.n68 a_6924_41600.t4 0.20525
R2550 a_6924_41600.n66 a_6924_41600.t1 0.20525
R2551 a_6924_41600.n66 a_6924_41600.t2 0.20525
R2552 a_6924_41600.n67 a_6924_41600.n65 0.189974
R2553 a_6924_41600.n69 a_6924_41600.n67 0.189974
R2554 a_6924_41600.n4 a_6924_41600.n3 0.189974
R2555 a_6924_41600.n3 a_6924_41600.n1 0.189974
R2556 a_6924_41600.n57 a_6924_41600.n34 0.1205
R2557 a_6924_41600.n57 a_6924_41600.n56 0.1205
R2558 a_6924_41600.n56 a_6924_41600.n55 0.1205
R2559 a_6924_41600.n55 a_6924_41600.n48 0.1205
R2560 a_6924_41600.n51 a_6924_41600.n48 0.1205
R2561 a_6924_41600.n39 a_6924_41600.n38 0.1205
R2562 a_6924_41600.n38 a_6924_41600.n37 0.1205
R2563 a_6924_41600.n37 a_6924_41600.n36 0.1205
R2564 a_6924_41600.n36 a_6924_41600.n35 0.1205
R2565 a_6924_41600.n61 a_6924_41600.n35 0.1205
R2566 a_6924_41600.n28 a_6924_41600.n5 0.1205
R2567 a_6924_41600.n28 a_6924_41600.n27 0.1205
R2568 a_6924_41600.n27 a_6924_41600.n26 0.1205
R2569 a_6924_41600.n26 a_6924_41600.n19 0.1205
R2570 a_6924_41600.n22 a_6924_41600.n19 0.1205
R2571 a_6924_41600.n10 a_6924_41600.n9 0.1205
R2572 a_6924_41600.n9 a_6924_41600.n8 0.1205
R2573 a_6924_41600.n8 a_6924_41600.n7 0.1205
R2574 a_6924_41600.n7 a_6924_41600.n6 0.1205
R2575 a_6924_41600.n32 a_6924_41600.n6 0.1205
R2576 a_6924_41600.n62 a_6924_41600.n34 0.0485
R2577 a_6924_41600.n62 a_6924_41600.n61 0.0485
R2578 a_6924_41600.n33 a_6924_41600.n5 0.0485
R2579 a_6924_41600.n33 a_6924_41600.n32 0.0485
R2580 a_4812_41600.n18 a_4812_41600.t15 113.632
R2581 a_4812_41600.n22 a_4812_41600.t8 113.632
R2582 a_4812_41600.n5 a_4812_41600.t23 113.632
R2583 a_4812_41600.n9 a_4812_41600.t16 113.632
R2584 a_4812_41600.n25 a_4812_41600.t11 109.174
R2585 a_4812_41600.n26 a_4812_41600.t12 109.174
R2586 a_4812_41600.n19 a_4812_41600.t14 109.174
R2587 a_4812_41600.n20 a_4812_41600.t13 109.174
R2588 a_4812_41600.n24 a_4812_41600.t10 109.174
R2589 a_4812_41600.n21 a_4812_41600.t9 109.174
R2590 a_4812_41600.n12 a_4812_41600.t19 109.174
R2591 a_4812_41600.n13 a_4812_41600.t20 109.174
R2592 a_4812_41600.n6 a_4812_41600.t22 109.174
R2593 a_4812_41600.n7 a_4812_41600.t21 109.174
R2594 a_4812_41600.n11 a_4812_41600.t18 109.174
R2595 a_4812_41600.n8 a_4812_41600.t17 109.174
R2596 a_4812_41600.n25 a_4812_41600.n16 18.4942
R2597 a_4812_41600.n27 a_4812_41600.n26 18.4942
R2598 a_4812_41600.n20 a_4812_41600.n17 18.4942
R2599 a_4812_41600.n24 a_4812_41600.n23 18.4942
R2600 a_4812_41600.n12 a_4812_41600.n3 18.4942
R2601 a_4812_41600.n14 a_4812_41600.n13 18.4942
R2602 a_4812_41600.n7 a_4812_41600.n4 18.4942
R2603 a_4812_41600.n11 a_4812_41600.n10 18.4942
R2604 a_4812_41600.n30 a_4812_41600.n29 17.6174
R2605 a_4812_41600.n25 a_4812_41600.n24 11.6805
R2606 a_4812_41600.n26 a_4812_41600.n25 11.6805
R2607 a_4812_41600.n20 a_4812_41600.n19 11.6805
R2608 a_4812_41600.n26 a_4812_41600.n20 11.6805
R2609 a_4812_41600.n24 a_4812_41600.n21 11.6805
R2610 a_4812_41600.n12 a_4812_41600.n11 11.6805
R2611 a_4812_41600.n13 a_4812_41600.n12 11.6805
R2612 a_4812_41600.n7 a_4812_41600.n6 11.6805
R2613 a_4812_41600.n13 a_4812_41600.n7 11.6805
R2614 a_4812_41600.n11 a_4812_41600.n8 11.6805
R2615 a_4812_41600.n29 a_4812_41600.n15 10.3505
R2616 a_4812_41600.n29 a_4812_41600.n28 9.57907
R2617 a_4812_41600.n23 a_4812_41600.n22 7.17687
R2618 a_4812_41600.n18 a_4812_41600.n17 7.17687
R2619 a_4812_41600.n10 a_4812_41600.n9 7.17687
R2620 a_4812_41600.n5 a_4812_41600.n4 7.17687
R2621 a_4812_41600.n30 a_4812_41600.n2 6.5392
R2622 a_4812_41600.t3 a_4812_41600.n33 5.7796
R2623 a_4812_41600.n1 a_4812_41600.t7 5.73764
R2624 a_4812_41600.n31 a_4812_41600.t0 5.59012
R2625 a_4812_41600.n2 a_4812_41600.t4 5.54817
R2626 a_4812_41600.n33 a_4812_41600.n32 5.38537
R2627 a_4812_41600.n1 a_4812_41600.n0 5.32067
R2628 a_4812_41600.n31 a_4812_41600.n30 4.61063
R2629 a_4812_41600.n19 a_4812_41600.n18 4.42851
R2630 a_4812_41600.n22 a_4812_41600.n21 4.42851
R2631 a_4812_41600.n6 a_4812_41600.n5 4.42851
R2632 a_4812_41600.n9 a_4812_41600.n8 4.42851
R2633 a_4812_41600.n0 a_4812_41600.t5 0.228
R2634 a_4812_41600.n0 a_4812_41600.t6 0.228
R2635 a_4812_41600.n32 a_4812_41600.t1 0.20525
R2636 a_4812_41600.n32 a_4812_41600.t2 0.20525
R2637 a_4812_41600.n33 a_4812_41600.n31 0.189974
R2638 a_4812_41600.n2 a_4812_41600.n1 0.189974
R2639 a_4812_41600.n23 a_4812_41600.n16 0.1205
R2640 a_4812_41600.n27 a_4812_41600.n17 0.1205
R2641 a_4812_41600.n10 a_4812_41600.n3 0.1205
R2642 a_4812_41600.n14 a_4812_41600.n4 0.1205
R2643 a_4812_41600.n28 a_4812_41600.n16 0.0485
R2644 a_4812_41600.n28 a_4812_41600.n27 0.0485
R2645 a_4812_41600.n15 a_4812_41600.n3 0.0485
R2646 a_4812_41600.n15 a_4812_41600.n14 0.0485
R2647 a_2700_41600.n18 a_2700_41600.t15 113.632
R2648 a_2700_41600.n22 a_2700_41600.t8 113.632
R2649 a_2700_41600.n5 a_2700_41600.t23 113.632
R2650 a_2700_41600.n9 a_2700_41600.t16 113.632
R2651 a_2700_41600.n25 a_2700_41600.t11 109.174
R2652 a_2700_41600.n26 a_2700_41600.t12 109.174
R2653 a_2700_41600.n19 a_2700_41600.t14 109.174
R2654 a_2700_41600.n20 a_2700_41600.t13 109.174
R2655 a_2700_41600.n24 a_2700_41600.t10 109.174
R2656 a_2700_41600.n21 a_2700_41600.t9 109.174
R2657 a_2700_41600.n12 a_2700_41600.t19 109.174
R2658 a_2700_41600.n13 a_2700_41600.t20 109.174
R2659 a_2700_41600.n6 a_2700_41600.t22 109.174
R2660 a_2700_41600.n7 a_2700_41600.t21 109.174
R2661 a_2700_41600.n11 a_2700_41600.t18 109.174
R2662 a_2700_41600.n8 a_2700_41600.t17 109.174
R2663 a_2700_41600.n25 a_2700_41600.n16 18.4942
R2664 a_2700_41600.n27 a_2700_41600.n26 18.4942
R2665 a_2700_41600.n20 a_2700_41600.n17 18.4942
R2666 a_2700_41600.n24 a_2700_41600.n23 18.4942
R2667 a_2700_41600.n12 a_2700_41600.n3 18.4942
R2668 a_2700_41600.n14 a_2700_41600.n13 18.4942
R2669 a_2700_41600.n7 a_2700_41600.n4 18.4942
R2670 a_2700_41600.n11 a_2700_41600.n10 18.4942
R2671 a_2700_41600.n30 a_2700_41600.n29 17.3289
R2672 a_2700_41600.n25 a_2700_41600.n24 11.6805
R2673 a_2700_41600.n26 a_2700_41600.n25 11.6805
R2674 a_2700_41600.n20 a_2700_41600.n19 11.6805
R2675 a_2700_41600.n26 a_2700_41600.n20 11.6805
R2676 a_2700_41600.n24 a_2700_41600.n21 11.6805
R2677 a_2700_41600.n12 a_2700_41600.n11 11.6805
R2678 a_2700_41600.n13 a_2700_41600.n12 11.6805
R2679 a_2700_41600.n7 a_2700_41600.n6 11.6805
R2680 a_2700_41600.n13 a_2700_41600.n7 11.6805
R2681 a_2700_41600.n11 a_2700_41600.n8 11.6805
R2682 a_2700_41600.n29 a_2700_41600.n15 10.688
R2683 a_2700_41600.n29 a_2700_41600.n28 9.24157
R2684 a_2700_41600.n23 a_2700_41600.n22 7.17687
R2685 a_2700_41600.n18 a_2700_41600.n17 7.17687
R2686 a_2700_41600.n10 a_2700_41600.n9 7.17687
R2687 a_2700_41600.n5 a_2700_41600.n4 7.17687
R2688 a_2700_41600.n30 a_2700_41600.n2 6.5392
R2689 a_2700_41600.t3 a_2700_41600.n33 5.7796
R2690 a_2700_41600.n1 a_2700_41600.t7 5.73764
R2691 a_2700_41600.n31 a_2700_41600.t0 5.59012
R2692 a_2700_41600.n2 a_2700_41600.t4 5.54817
R2693 a_2700_41600.n33 a_2700_41600.n32 5.38537
R2694 a_2700_41600.n1 a_2700_41600.n0 5.32067
R2695 a_2700_41600.n31 a_2700_41600.n30 4.61063
R2696 a_2700_41600.n19 a_2700_41600.n18 4.42851
R2697 a_2700_41600.n22 a_2700_41600.n21 4.42851
R2698 a_2700_41600.n6 a_2700_41600.n5 4.42851
R2699 a_2700_41600.n9 a_2700_41600.n8 4.42851
R2700 a_2700_41600.n0 a_2700_41600.t5 0.228
R2701 a_2700_41600.n0 a_2700_41600.t6 0.228
R2702 a_2700_41600.n32 a_2700_41600.t1 0.20525
R2703 a_2700_41600.n32 a_2700_41600.t2 0.20525
R2704 a_2700_41600.n33 a_2700_41600.n31 0.189974
R2705 a_2700_41600.n2 a_2700_41600.n1 0.189974
R2706 a_2700_41600.n23 a_2700_41600.n16 0.1205
R2707 a_2700_41600.n27 a_2700_41600.n17 0.1205
R2708 a_2700_41600.n10 a_2700_41600.n3 0.1205
R2709 a_2700_41600.n14 a_2700_41600.n4 0.1205
R2710 a_2700_41600.n28 a_2700_41600.n16 0.0485
R2711 a_2700_41600.n28 a_2700_41600.n27 0.0485
R2712 a_2700_41600.n15 a_2700_41600.n3 0.0485
R2713 a_2700_41600.n15 a_2700_41600.n14 0.0485
C0 E_SENSE VDD 40.93f
C1 VDD CLKN_HB 3.82661f
C2 E_CAPTURE_CLK VDD 11.2501f
C3 O_CAPTURE_CLKB O_CAPTURE_CLK 0.13895f
C4 CLKN_HB CLKN_H 0.13381f
C5 CLKP_HB VDD 3.82661f
C6 E_CAPTURE_CLKB VDD 11.3088f
C7 CLKP_HB CLKP_H 0.13381f
C8 VDD CLKN_H 2.93876f
C9 CLKP_H VDD 2.93876f
C10 E_CAPTURE_CLK E_CAPTURE_CLKB 0.13895f
C11 O_SENSE VDD 40.93f
C12 O_CAPTURE_CLK VDD 11.2501f
C13 O_CAPTURE_CLKB VDD 11.3088f
C14 E_SENSE VSS 45.75606f
C15 E_CAPTURE_CLK VSS 13.22105f
C16 E_CAPTURE_CLKB VSS 11.56589f
C17 CLKP_H VSS 8.92236f
C18 CLKP_HB VSS 11.54082f
C19 O_SENSE VSS 45.75606f
C20 O_CAPTURE_CLK VSS 13.22105f
C21 O_CAPTURE_CLKB VSS 11.56589f
C22 CLKN_H VSS 8.92236f
C23 CLKN_HB VSS 12.01012f
C24 VDD VSS 2.54189p
C25 a_2700_41600.t7 VSS 0.78893f
C26 a_2700_41600.t6 VSS 0.18225f
C27 a_2700_41600.t5 VSS 0.18225f
C28 a_2700_41600.n0 VSS 0.5825f
C29 a_2700_41600.n1 VSS 0.32018f
C30 a_2700_41600.t4 VSS 0.7837f
C31 a_2700_41600.n2 VSS 0.34581f
C32 a_2700_41600.n3 VSS 0.05385f
C33 a_2700_41600.n4 VSS 0.18602f
C34 a_2700_41600.n5 VSS 0.09195f
C35 a_2700_41600.n6 VSS 0.09856f
C36 a_2700_41600.n7 VSS 0.09856f
C37 a_2700_41600.n8 VSS 0.09856f
C38 a_2700_41600.n9 VSS 0.09195f
C39 a_2700_41600.n10 VSS 0.18602f
C40 a_2700_41600.n11 VSS 0.09856f
C41 a_2700_41600.n12 VSS 0.09856f
C42 a_2700_41600.n13 VSS 0.09856f
C43 a_2700_41600.n14 VSS 0.05385f
C44 a_2700_41600.n15 VSS 0.30229f
C45 a_2700_41600.n16 VSS 0.05385f
C46 a_2700_41600.n17 VSS 0.18602f
C47 a_2700_41600.n18 VSS 0.09195f
C48 a_2700_41600.n19 VSS 0.09856f
C49 a_2700_41600.n20 VSS 0.09856f
C50 a_2700_41600.n21 VSS 0.09856f
C51 a_2700_41600.n22 VSS 0.09195f
C52 a_2700_41600.n23 VSS 0.18602f
C53 a_2700_41600.n24 VSS 0.09856f
C54 a_2700_41600.n25 VSS 0.09856f
C55 a_2700_41600.n26 VSS 0.09856f
C56 a_2700_41600.n27 VSS 0.05385f
C57 a_2700_41600.n28 VSS 0.22641f
C58 a_2700_41600.n29 VSS 2.07071f
C59 a_2700_41600.n30 VSS 1.92619f
C60 a_2700_41600.t0 VSS 0.7823f
C61 a_2700_41600.n31 VSS 0.23448f
C62 a_2700_41600.t2 VSS 0.18225f
C63 a_2700_41600.t1 VSS 0.18225f
C64 a_2700_41600.n32 VSS 0.5782f
C65 a_2700_41600.n33 VSS 0.32586f
C66 a_2700_41600.t3 VSS 0.78754f
C67 a_4812_41600.t7 VSS 0.81391f
C68 a_4812_41600.t6 VSS 0.18057f
C69 a_4812_41600.t5 VSS 0.18057f
C70 a_4812_41600.n0 VSS 0.60827f
C71 a_4812_41600.n1 VSS 0.33435f
C72 a_4812_41600.t4 VSS 0.80845f
C73 a_4812_41600.n2 VSS 0.36111f
C74 a_4812_41600.n3 VSS 0.05623f
C75 a_4812_41600.n4 VSS 0.19425f
C76 a_4812_41600.n5 VSS 0.09601f
C77 a_4812_41600.n6 VSS 0.10292f
C78 a_4812_41600.n7 VSS 0.10292f
C79 a_4812_41600.n8 VSS 0.10292f
C80 a_4812_41600.n9 VSS 0.09601f
C81 a_4812_41600.n10 VSS 0.19425f
C82 a_4812_41600.n11 VSS 0.10292f
C83 a_4812_41600.n12 VSS 0.10292f
C84 a_4812_41600.n13 VSS 0.10292f
C85 a_4812_41600.n14 VSS 0.05623f
C86 a_4812_41600.n15 VSS 0.29204f
C87 a_4812_41600.n16 VSS 0.05623f
C88 a_4812_41600.n17 VSS 0.19425f
C89 a_4812_41600.n18 VSS 0.09601f
C90 a_4812_41600.n19 VSS 0.10292f
C91 a_4812_41600.n20 VSS 0.10292f
C92 a_4812_41600.n21 VSS 0.10292f
C93 a_4812_41600.n22 VSS 0.09601f
C94 a_4812_41600.n23 VSS 0.19425f
C95 a_4812_41600.n24 VSS 0.10292f
C96 a_4812_41600.n25 VSS 0.10292f
C97 a_4812_41600.n26 VSS 0.10292f
C98 a_4812_41600.n27 VSS 0.05623f
C99 a_4812_41600.n28 VSS 0.24937f
C100 a_4812_41600.n29 VSS 2.23232f
C101 a_4812_41600.n30 VSS 1.98559f
C102 a_4812_41600.t0 VSS 0.80699f
C103 a_4812_41600.n31 VSS 0.24486f
C104 a_4812_41600.t2 VSS 0.18057f
C105 a_4812_41600.t1 VSS 0.18057f
C106 a_4812_41600.n32 VSS 0.60379f
C107 a_4812_41600.n33 VSS 0.34029f
C108 a_4812_41600.t3 VSS 0.81246f
C109 a_6924_41600.t11 VSS 0.77377f
C110 a_6924_41600.t10 VSS 0.17987f
C111 a_6924_41600.t9 VSS 0.17987f
C112 a_6924_41600.n0 VSS 0.5702f
C113 a_6924_41600.n1 VSS 0.31342f
C114 a_6924_41600.t8 VSS 0.17987f
C115 a_6924_41600.t7 VSS 0.17987f
C116 a_6924_41600.n2 VSS 0.5702f
C117 a_6924_41600.n3 VSS 0.16361f
C118 a_6924_41600.t6 VSS 0.76865f
C119 a_6924_41600.n4 VSS 0.33851f
C120 a_6924_41600.n5 VSS 0.05271f
C121 a_6924_41600.n6 VSS 0.06256f
C122 a_6924_41600.n7 VSS 0.06256f
C123 a_6924_41600.n8 VSS 0.06256f
C124 a_6924_41600.n9 VSS 0.06256f
C125 a_6924_41600.n10 VSS 0.18209f
C126 a_6924_41600.n11 VSS 0.09f
C127 a_6924_41600.n12 VSS 0.09648f
C128 a_6924_41600.n13 VSS 0.09648f
C129 a_6924_41600.n14 VSS 0.09648f
C130 a_6924_41600.n15 VSS 0.09648f
C131 a_6924_41600.n16 VSS 0.09648f
C132 a_6924_41600.n17 VSS 0.09648f
C133 a_6924_41600.n18 VSS 0.09648f
C134 a_6924_41600.n19 VSS 0.06256f
C135 a_6924_41600.n20 VSS 0.09648f
C136 a_6924_41600.n21 VSS 0.09f
C137 a_6924_41600.n22 VSS 0.18209f
C138 a_6924_41600.n23 VSS 0.09648f
C139 a_6924_41600.n24 VSS 0.09648f
C140 a_6924_41600.n25 VSS 0.09648f
C141 a_6924_41600.n26 VSS 0.06256f
C142 a_6924_41600.n27 VSS 0.06256f
C143 a_6924_41600.n28 VSS 0.06256f
C144 a_6924_41600.n29 VSS 0.09648f
C145 a_6924_41600.n30 VSS 0.09648f
C146 a_6924_41600.n31 VSS 0.09648f
C147 a_6924_41600.n32 VSS 0.05271f
C148 a_6924_41600.n33 VSS 0.46332f
C149 a_6924_41600.n34 VSS 0.05271f
C150 a_6924_41600.n35 VSS 0.06256f
C151 a_6924_41600.n36 VSS 0.06256f
C152 a_6924_41600.n37 VSS 0.06256f
C153 a_6924_41600.n38 VSS 0.06256f
C154 a_6924_41600.n39 VSS 0.18209f
C155 a_6924_41600.n40 VSS 0.09f
C156 a_6924_41600.n41 VSS 0.09648f
C157 a_6924_41600.n42 VSS 0.09648f
C158 a_6924_41600.n43 VSS 0.09648f
C159 a_6924_41600.n44 VSS 0.09648f
C160 a_6924_41600.n45 VSS 0.09648f
C161 a_6924_41600.n46 VSS 0.09648f
C162 a_6924_41600.n47 VSS 0.09648f
C163 a_6924_41600.n48 VSS 0.06256f
C164 a_6924_41600.n49 VSS 0.09648f
C165 a_6924_41600.n50 VSS 0.09f
C166 a_6924_41600.n51 VSS 0.18209f
C167 a_6924_41600.n52 VSS 0.09648f
C168 a_6924_41600.n53 VSS 0.09648f
C169 a_6924_41600.n54 VSS 0.09648f
C170 a_6924_41600.n55 VSS 0.06256f
C171 a_6924_41600.n56 VSS 0.06256f
C172 a_6924_41600.n57 VSS 0.06256f
C173 a_6924_41600.n58 VSS 0.09648f
C174 a_6924_41600.n59 VSS 0.09648f
C175 a_6924_41600.n60 VSS 0.09648f
C176 a_6924_41600.n61 VSS 0.05271f
C177 a_6924_41600.n62 VSS 0.45664f
C178 a_6924_41600.n63 VSS 2.57374f
C179 a_6924_41600.n64 VSS 1.91419f
C180 a_6924_41600.t0 VSS 0.76728f
C181 a_6924_41600.n65 VSS 0.22953f
C182 a_6924_41600.t2 VSS 0.17987f
C183 a_6924_41600.t1 VSS 0.17987f
C184 a_6924_41600.n66 VSS 0.56599f
C185 a_6924_41600.n67 VSS 0.16782f
C186 a_6924_41600.t4 VSS 0.17987f
C187 a_6924_41600.t3 VSS 0.17987f
C188 a_6924_41600.n68 VSS 0.56599f
C189 a_6924_41600.n69 VSS 0.31898f
C190 a_6924_41600.t5 VSS 0.77241f
C191 a_14860_41600.t1 VSS 0.20597f
C192 a_14860_41600.t21 VSS 0.81066f
C193 a_14860_41600.t8 VSS 0.20597f
C194 a_14860_41600.t9 VSS 0.20597f
C195 a_14860_41600.n0 VSS 0.57718f
C196 a_14860_41600.n1 VSS 0.32529f
C197 a_14860_41600.t26 VSS 0.20597f
C198 a_14860_41600.t27 VSS 0.20597f
C199 a_14860_41600.n2 VSS 0.57718f
C200 a_14860_41600.n3 VSS 0.17113f
C201 a_14860_41600.t6 VSS 0.20597f
C202 a_14860_41600.t7 VSS 0.20597f
C203 a_14860_41600.n4 VSS 0.57718f
C204 a_14860_41600.n5 VSS 0.17113f
C205 a_14860_41600.t30 VSS 0.20597f
C206 a_14860_41600.t31 VSS 0.20597f
C207 a_14860_41600.n6 VSS 0.57718f
C208 a_14860_41600.n7 VSS 0.17113f
C209 a_14860_41600.t2 VSS 0.20597f
C210 a_14860_41600.t3 VSS 0.20597f
C211 a_14860_41600.n8 VSS 0.57718f
C212 a_14860_41600.n9 VSS 0.17113f
C213 a_14860_41600.t20 VSS 0.81205f
C214 a_14860_41600.t11 VSS 0.20597f
C215 a_14860_41600.t12 VSS 0.20597f
C216 a_14860_41600.n10 VSS 0.58147f
C217 a_14860_41600.n11 VSS 0.31962f
C218 a_14860_41600.t4 VSS 0.20597f
C219 a_14860_41600.t5 VSS 0.20597f
C220 a_14860_41600.n12 VSS 0.58147f
C221 a_14860_41600.n13 VSS 0.16685f
C222 a_14860_41600.t28 VSS 0.20597f
C223 a_14860_41600.t29 VSS 0.20597f
C224 a_14860_41600.n14 VSS 0.58147f
C225 a_14860_41600.n15 VSS 0.16685f
C226 a_14860_41600.t15 VSS 0.20597f
C227 a_14860_41600.t16 VSS 0.20597f
C228 a_14860_41600.n16 VSS 0.58147f
C229 a_14860_41600.n17 VSS 0.16685f
C230 a_14860_41600.t13 VSS 0.20597f
C231 a_14860_41600.t14 VSS 0.20597f
C232 a_14860_41600.n18 VSS 0.58147f
C233 a_14860_41600.n19 VSS 0.16685f
C234 a_14860_41600.t24 VSS 0.20597f
C235 a_14860_41600.t25 VSS 0.20597f
C236 a_14860_41600.n20 VSS 0.58147f
C237 a_14860_41600.n21 VSS 0.16685f
C238 a_14860_41600.t17 VSS 0.20597f
C239 a_14860_41600.t18 VSS 0.20597f
C240 a_14860_41600.n22 VSS 0.58147f
C241 a_14860_41600.n23 VSS 0.16685f
C242 a_14860_41600.t10 VSS 0.80683f
C243 a_14860_41600.n24 VSS 0.3452f
C244 a_14860_41600.n25 VSS 0.05375f
C245 a_14860_41600.n26 VSS 0.0638f
C246 a_14860_41600.n27 VSS 0.0638f
C247 a_14860_41600.n28 VSS 0.0638f
C248 a_14860_41600.n29 VSS 0.0638f
C249 a_14860_41600.n30 VSS 0.0638f
C250 a_14860_41600.n31 VSS 0.0638f
C251 a_14860_41600.n32 VSS 0.0638f
C252 a_14860_41600.n33 VSS 0.0638f
C253 a_14860_41600.n34 VSS 0.0638f
C254 a_14860_41600.n35 VSS 0.0638f
C255 a_14860_41600.n36 VSS 0.0638f
C256 a_14860_41600.n37 VSS 0.0638f
C257 a_14860_41600.n38 VSS 0.18569f
C258 a_14860_41600.n39 VSS 0.09178f
C259 a_14860_41600.n40 VSS 0.09838f
C260 a_14860_41600.n41 VSS 0.09838f
C261 a_14860_41600.n42 VSS 0.09838f
C262 a_14860_41600.n43 VSS 0.09838f
C263 a_14860_41600.n44 VSS 0.09838f
C264 a_14860_41600.n45 VSS 0.09838f
C265 a_14860_41600.n46 VSS 0.09838f
C266 a_14860_41600.n47 VSS 0.09838f
C267 a_14860_41600.n48 VSS 0.09838f
C268 a_14860_41600.n49 VSS 0.09838f
C269 a_14860_41600.n50 VSS 0.09838f
C270 a_14860_41600.n51 VSS 0.09838f
C271 a_14860_41600.n52 VSS 0.09838f
C272 a_14860_41600.n53 VSS 0.09838f
C273 a_14860_41600.n54 VSS 0.09838f
C274 a_14860_41600.n55 VSS 0.0638f
C275 a_14860_41600.n56 VSS 0.09838f
C276 a_14860_41600.n57 VSS 0.0638f
C277 a_14860_41600.n58 VSS 0.09838f
C278 a_14860_41600.n59 VSS 0.0638f
C279 a_14860_41600.n60 VSS 0.09838f
C280 a_14860_41600.n61 VSS 0.09178f
C281 a_14860_41600.n62 VSS 0.18569f
C282 a_14860_41600.n63 VSS 0.09838f
C283 a_14860_41600.n64 VSS 0.09838f
C284 a_14860_41600.n65 VSS 0.09838f
C285 a_14860_41600.n66 VSS 0.0638f
C286 a_14860_41600.n67 VSS 0.0638f
C287 a_14860_41600.n68 VSS 0.0638f
C288 a_14860_41600.n69 VSS 0.09838f
C289 a_14860_41600.n70 VSS 0.09838f
C290 a_14860_41600.n71 VSS 0.09838f
C291 a_14860_41600.n72 VSS 0.0638f
C292 a_14860_41600.n73 VSS 0.0638f
C293 a_14860_41600.n74 VSS 0.0638f
C294 a_14860_41600.n75 VSS 0.09838f
C295 a_14860_41600.n76 VSS 0.09838f
C296 a_14860_41600.n77 VSS 0.09838f
C297 a_14860_41600.n78 VSS 0.0638f
C298 a_14860_41600.n79 VSS 0.0638f
C299 a_14860_41600.n80 VSS 0.0638f
C300 a_14860_41600.n81 VSS 0.09838f
C301 a_14860_41600.n82 VSS 0.09838f
C302 a_14860_41600.n83 VSS 0.09838f
C303 a_14860_41600.n84 VSS 0.05375f
C304 a_14860_41600.n85 VSS 0.97413f
C305 a_14860_41600.n86 VSS 0.05375f
C306 a_14860_41600.n87 VSS 0.0638f
C307 a_14860_41600.n88 VSS 0.0638f
C308 a_14860_41600.n89 VSS 0.0638f
C309 a_14860_41600.n90 VSS 0.0638f
C310 a_14860_41600.n91 VSS 0.0638f
C311 a_14860_41600.n92 VSS 0.0638f
C312 a_14860_41600.n93 VSS 0.0638f
C313 a_14860_41600.n94 VSS 0.0638f
C314 a_14860_41600.n95 VSS 0.0638f
C315 a_14860_41600.n96 VSS 0.0638f
C316 a_14860_41600.n97 VSS 0.0638f
C317 a_14860_41600.n98 VSS 0.0638f
C318 a_14860_41600.n99 VSS 0.18569f
C319 a_14860_41600.n100 VSS 0.09178f
C320 a_14860_41600.n101 VSS 0.09838f
C321 a_14860_41600.n102 VSS 0.09838f
C322 a_14860_41600.n103 VSS 0.09838f
C323 a_14860_41600.n104 VSS 0.09838f
C324 a_14860_41600.n105 VSS 0.09838f
C325 a_14860_41600.n106 VSS 0.09838f
C326 a_14860_41600.n107 VSS 0.09838f
C327 a_14860_41600.n108 VSS 0.09838f
C328 a_14860_41600.n109 VSS 0.09838f
C329 a_14860_41600.n110 VSS 0.09838f
C330 a_14860_41600.n111 VSS 0.09838f
C331 a_14860_41600.n112 VSS 0.09838f
C332 a_14860_41600.n113 VSS 0.09838f
C333 a_14860_41600.n114 VSS 0.09838f
C334 a_14860_41600.n115 VSS 0.09838f
C335 a_14860_41600.n116 VSS 0.0638f
C336 a_14860_41600.n117 VSS 0.09838f
C337 a_14860_41600.n118 VSS 0.0638f
C338 a_14860_41600.n119 VSS 0.09838f
C339 a_14860_41600.n120 VSS 0.0638f
C340 a_14860_41600.n121 VSS 0.09838f
C341 a_14860_41600.n122 VSS 0.09178f
C342 a_14860_41600.n123 VSS 0.18569f
C343 a_14860_41600.n124 VSS 0.09838f
C344 a_14860_41600.n125 VSS 0.09838f
C345 a_14860_41600.n126 VSS 0.09838f
C346 a_14860_41600.n127 VSS 0.0638f
C347 a_14860_41600.n128 VSS 0.0638f
C348 a_14860_41600.n129 VSS 0.0638f
C349 a_14860_41600.n130 VSS 0.09838f
C350 a_14860_41600.n131 VSS 0.09838f
C351 a_14860_41600.n132 VSS 0.09838f
C352 a_14860_41600.n133 VSS 0.0638f
C353 a_14860_41600.n134 VSS 0.0638f
C354 a_14860_41600.n135 VSS 0.0638f
C355 a_14860_41600.n136 VSS 0.09838f
C356 a_14860_41600.n137 VSS 0.09838f
C357 a_14860_41600.n138 VSS 0.09838f
C358 a_14860_41600.n139 VSS 0.0638f
C359 a_14860_41600.n140 VSS 0.0638f
C360 a_14860_41600.n141 VSS 0.0638f
C361 a_14860_41600.n142 VSS 0.09838f
C362 a_14860_41600.n143 VSS 0.09838f
C363 a_14860_41600.n144 VSS 0.09838f
C364 a_14860_41600.n145 VSS 0.05375f
C365 a_14860_41600.n146 VSS 0.82184f
C366 a_14860_41600.n147 VSS 3.0316f
C367 a_14860_41600.n148 VSS 1.8379f
C368 a_14860_41600.t19 VSS 0.80543f
C369 a_14860_41600.n149 VSS 0.23407f
C370 a_14860_41600.t22 VSS 0.20597f
C371 a_14860_41600.t23 VSS 0.20597f
C372 a_14860_41600.n150 VSS 0.57718f
C373 a_14860_41600.n151 VSS 0.17113f
C374 a_14860_41600.n152 VSS 0.17113f
C375 a_14860_41600.n153 VSS 0.57718f
C376 a_14860_41600.t0 VSS 0.20597f
C377 a_2700_6400.t7 VSS 0.79013f
C378 a_2700_6400.t6 VSS 0.18342f
C379 a_2700_6400.t5 VSS 0.18342f
C380 a_2700_6400.n0 VSS 0.5825f
C381 a_2700_6400.n1 VSS 0.32018f
C382 a_2700_6400.t4 VSS 0.7849f
C383 a_2700_6400.n2 VSS 0.34581f
C384 a_2700_6400.n3 VSS 0.05385f
C385 a_2700_6400.n4 VSS 0.18602f
C386 a_2700_6400.n5 VSS 0.09195f
C387 a_2700_6400.n6 VSS 0.09856f
C388 a_2700_6400.n7 VSS 0.09856f
C389 a_2700_6400.n8 VSS 0.09856f
C390 a_2700_6400.n9 VSS 0.09195f
C391 a_2700_6400.n10 VSS 0.18602f
C392 a_2700_6400.n11 VSS 0.09856f
C393 a_2700_6400.n12 VSS 0.09856f
C394 a_2700_6400.n13 VSS 0.09856f
C395 a_2700_6400.n14 VSS 0.05385f
C396 a_2700_6400.n15 VSS 0.30229f
C397 a_2700_6400.n16 VSS 0.05385f
C398 a_2700_6400.n17 VSS 0.18602f
C399 a_2700_6400.n18 VSS 0.09195f
C400 a_2700_6400.n19 VSS 0.09856f
C401 a_2700_6400.n20 VSS 0.09856f
C402 a_2700_6400.n21 VSS 0.09856f
C403 a_2700_6400.n22 VSS 0.09195f
C404 a_2700_6400.n23 VSS 0.18602f
C405 a_2700_6400.n24 VSS 0.09856f
C406 a_2700_6400.n25 VSS 0.09856f
C407 a_2700_6400.n26 VSS 0.09856f
C408 a_2700_6400.n27 VSS 0.05385f
C409 a_2700_6400.n28 VSS 0.22641f
C410 a_2700_6400.n29 VSS 2.07071f
C411 a_2700_6400.n30 VSS 1.92619f
C412 a_2700_6400.t0 VSS 0.7835f
C413 a_2700_6400.n31 VSS 0.23448f
C414 a_2700_6400.t2 VSS 0.18342f
C415 a_2700_6400.t1 VSS 0.18342f
C416 a_2700_6400.n32 VSS 0.5782f
C417 a_2700_6400.n33 VSS 0.32586f
C418 a_2700_6400.t3 VSS 0.78874f
C419 a_4812_6400.t7 VSS 0.81391f
C420 a_4812_6400.t6 VSS 0.18057f
C421 a_4812_6400.t5 VSS 0.18057f
C422 a_4812_6400.n0 VSS 0.60827f
C423 a_4812_6400.n1 VSS 0.33435f
C424 a_4812_6400.t4 VSS 0.80845f
C425 a_4812_6400.n2 VSS 0.36111f
C426 a_4812_6400.n3 VSS 0.05623f
C427 a_4812_6400.n4 VSS 0.19425f
C428 a_4812_6400.n5 VSS 0.09601f
C429 a_4812_6400.n6 VSS 0.10292f
C430 a_4812_6400.n7 VSS 0.10292f
C431 a_4812_6400.n8 VSS 0.10292f
C432 a_4812_6400.n9 VSS 0.09601f
C433 a_4812_6400.n10 VSS 0.19425f
C434 a_4812_6400.n11 VSS 0.10292f
C435 a_4812_6400.n12 VSS 0.10292f
C436 a_4812_6400.n13 VSS 0.10292f
C437 a_4812_6400.n14 VSS 0.05623f
C438 a_4812_6400.n15 VSS 0.29204f
C439 a_4812_6400.n16 VSS 0.05623f
C440 a_4812_6400.n17 VSS 0.19425f
C441 a_4812_6400.n18 VSS 0.09601f
C442 a_4812_6400.n19 VSS 0.10292f
C443 a_4812_6400.n20 VSS 0.10292f
C444 a_4812_6400.n21 VSS 0.10292f
C445 a_4812_6400.n22 VSS 0.09601f
C446 a_4812_6400.n23 VSS 0.19425f
C447 a_4812_6400.n24 VSS 0.10292f
C448 a_4812_6400.n25 VSS 0.10292f
C449 a_4812_6400.n26 VSS 0.10292f
C450 a_4812_6400.n27 VSS 0.05623f
C451 a_4812_6400.n28 VSS 0.24937f
C452 a_4812_6400.n29 VSS 2.23232f
C453 a_4812_6400.n30 VSS 1.98559f
C454 a_4812_6400.t0 VSS 0.80699f
C455 a_4812_6400.n31 VSS 0.24486f
C456 a_4812_6400.t2 VSS 0.18057f
C457 a_4812_6400.t1 VSS 0.18057f
C458 a_4812_6400.n32 VSS 0.60379f
C459 a_4812_6400.n33 VSS 0.34029f
C460 a_4812_6400.t3 VSS 0.81246f
C461 a_6924_6400.t11 VSS 0.77497f
C462 a_6924_6400.t10 VSS 0.18105f
C463 a_6924_6400.t9 VSS 0.18105f
C464 a_6924_6400.n0 VSS 0.5702f
C465 a_6924_6400.n1 VSS 0.31342f
C466 a_6924_6400.t8 VSS 0.18105f
C467 a_6924_6400.t7 VSS 0.18105f
C468 a_6924_6400.n2 VSS 0.5702f
C469 a_6924_6400.n3 VSS 0.16361f
C470 a_6924_6400.t6 VSS 0.76985f
C471 a_6924_6400.n4 VSS 0.33851f
C472 a_6924_6400.n5 VSS 0.05271f
C473 a_6924_6400.n6 VSS 0.06256f
C474 a_6924_6400.n7 VSS 0.06256f
C475 a_6924_6400.n8 VSS 0.06256f
C476 a_6924_6400.n9 VSS 0.06256f
C477 a_6924_6400.n10 VSS 0.18209f
C478 a_6924_6400.n11 VSS 0.09f
C479 a_6924_6400.n12 VSS 0.09648f
C480 a_6924_6400.n13 VSS 0.09648f
C481 a_6924_6400.n14 VSS 0.09648f
C482 a_6924_6400.n15 VSS 0.09648f
C483 a_6924_6400.n16 VSS 0.09648f
C484 a_6924_6400.n17 VSS 0.09648f
C485 a_6924_6400.n18 VSS 0.09648f
C486 a_6924_6400.n19 VSS 0.06256f
C487 a_6924_6400.n20 VSS 0.09648f
C488 a_6924_6400.n21 VSS 0.09f
C489 a_6924_6400.n22 VSS 0.18209f
C490 a_6924_6400.n23 VSS 0.09648f
C491 a_6924_6400.n24 VSS 0.09648f
C492 a_6924_6400.n25 VSS 0.09648f
C493 a_6924_6400.n26 VSS 0.06256f
C494 a_6924_6400.n27 VSS 0.06256f
C495 a_6924_6400.n28 VSS 0.06256f
C496 a_6924_6400.n29 VSS 0.09648f
C497 a_6924_6400.n30 VSS 0.09648f
C498 a_6924_6400.n31 VSS 0.09648f
C499 a_6924_6400.n32 VSS 0.05271f
C500 a_6924_6400.n33 VSS 0.46332f
C501 a_6924_6400.n34 VSS 0.05271f
C502 a_6924_6400.n35 VSS 0.06256f
C503 a_6924_6400.n36 VSS 0.06256f
C504 a_6924_6400.n37 VSS 0.06256f
C505 a_6924_6400.n38 VSS 0.06256f
C506 a_6924_6400.n39 VSS 0.18209f
C507 a_6924_6400.n40 VSS 0.09f
C508 a_6924_6400.n41 VSS 0.09648f
C509 a_6924_6400.n42 VSS 0.09648f
C510 a_6924_6400.n43 VSS 0.09648f
C511 a_6924_6400.n44 VSS 0.09648f
C512 a_6924_6400.n45 VSS 0.09648f
C513 a_6924_6400.n46 VSS 0.09648f
C514 a_6924_6400.n47 VSS 0.09648f
C515 a_6924_6400.n48 VSS 0.06256f
C516 a_6924_6400.n49 VSS 0.09648f
C517 a_6924_6400.n50 VSS 0.09f
C518 a_6924_6400.n51 VSS 0.18209f
C519 a_6924_6400.n52 VSS 0.09648f
C520 a_6924_6400.n53 VSS 0.09648f
C521 a_6924_6400.n54 VSS 0.09648f
C522 a_6924_6400.n55 VSS 0.06256f
C523 a_6924_6400.n56 VSS 0.06256f
C524 a_6924_6400.n57 VSS 0.06256f
C525 a_6924_6400.n58 VSS 0.09648f
C526 a_6924_6400.n59 VSS 0.09648f
C527 a_6924_6400.n60 VSS 0.09648f
C528 a_6924_6400.n61 VSS 0.05271f
C529 a_6924_6400.n62 VSS 0.45664f
C530 a_6924_6400.n63 VSS 2.57374f
C531 a_6924_6400.n64 VSS 1.91419f
C532 a_6924_6400.t0 VSS 0.76848f
C533 a_6924_6400.n65 VSS 0.22953f
C534 a_6924_6400.t2 VSS 0.18105f
C535 a_6924_6400.t1 VSS 0.18105f
C536 a_6924_6400.n66 VSS 0.56599f
C537 a_6924_6400.n67 VSS 0.16782f
C538 a_6924_6400.t4 VSS 0.18105f
C539 a_6924_6400.t3 VSS 0.18105f
C540 a_6924_6400.n68 VSS 0.56599f
C541 a_6924_6400.n69 VSS 0.31898f
C542 a_6924_6400.t5 VSS 0.77361f
C543 a_14860_6400.t23 VSS 0.20597f
C544 a_14860_6400.t10 VSS 0.81066f
C545 a_14860_6400.t11 VSS 0.20597f
C546 a_14860_6400.t6 VSS 0.20597f
C547 a_14860_6400.n0 VSS 0.57718f
C548 a_14860_6400.n1 VSS 0.32529f
C549 a_14860_6400.t7 VSS 0.20597f
C550 a_14860_6400.t2 VSS 0.20597f
C551 a_14860_6400.n2 VSS 0.57718f
C552 a_14860_6400.n3 VSS 0.17113f
C553 a_14860_6400.t3 VSS 0.20597f
C554 a_14860_6400.t22 VSS 0.20597f
C555 a_14860_6400.n4 VSS 0.57718f
C556 a_14860_6400.n5 VSS 0.17113f
C557 a_14860_6400.t24 VSS 0.81205f
C558 a_14860_6400.t25 VSS 0.20597f
C559 a_14860_6400.t30 VSS 0.20597f
C560 a_14860_6400.n6 VSS 0.58147f
C561 a_14860_6400.n7 VSS 0.31962f
C562 a_14860_6400.t31 VSS 0.20597f
C563 a_14860_6400.t12 VSS 0.20597f
C564 a_14860_6400.n8 VSS 0.58147f
C565 a_14860_6400.n9 VSS 0.16685f
C566 a_14860_6400.t13 VSS 0.20597f
C567 a_14860_6400.t8 VSS 0.20597f
C568 a_14860_6400.n10 VSS 0.58147f
C569 a_14860_6400.n11 VSS 0.16685f
C570 a_14860_6400.t9 VSS 0.20597f
C571 a_14860_6400.t20 VSS 0.20597f
C572 a_14860_6400.n12 VSS 0.58147f
C573 a_14860_6400.n13 VSS 0.16685f
C574 a_14860_6400.t21 VSS 0.20597f
C575 a_14860_6400.t16 VSS 0.20597f
C576 a_14860_6400.n14 VSS 0.58147f
C577 a_14860_6400.n15 VSS 0.16685f
C578 a_14860_6400.t17 VSS 0.20597f
C579 a_14860_6400.t26 VSS 0.20597f
C580 a_14860_6400.n16 VSS 0.58147f
C581 a_14860_6400.n17 VSS 0.16685f
C582 a_14860_6400.t27 VSS 0.20597f
C583 a_14860_6400.t14 VSS 0.20597f
C584 a_14860_6400.n18 VSS 0.58147f
C585 a_14860_6400.n19 VSS 0.16685f
C586 a_14860_6400.t15 VSS 0.80683f
C587 a_14860_6400.n20 VSS 0.3452f
C588 a_14860_6400.n21 VSS 0.05375f
C589 a_14860_6400.n22 VSS 0.0638f
C590 a_14860_6400.n23 VSS 0.0638f
C591 a_14860_6400.n24 VSS 0.0638f
C592 a_14860_6400.n25 VSS 0.0638f
C593 a_14860_6400.n26 VSS 0.0638f
C594 a_14860_6400.n27 VSS 0.0638f
C595 a_14860_6400.n28 VSS 0.0638f
C596 a_14860_6400.n29 VSS 0.0638f
C597 a_14860_6400.n30 VSS 0.0638f
C598 a_14860_6400.n31 VSS 0.0638f
C599 a_14860_6400.n32 VSS 0.0638f
C600 a_14860_6400.n33 VSS 0.0638f
C601 a_14860_6400.n34 VSS 0.18569f
C602 a_14860_6400.n35 VSS 0.09178f
C603 a_14860_6400.n36 VSS 0.09838f
C604 a_14860_6400.n37 VSS 0.09838f
C605 a_14860_6400.n38 VSS 0.09838f
C606 a_14860_6400.n39 VSS 0.09838f
C607 a_14860_6400.n40 VSS 0.09838f
C608 a_14860_6400.n41 VSS 0.09838f
C609 a_14860_6400.n42 VSS 0.09838f
C610 a_14860_6400.n43 VSS 0.09838f
C611 a_14860_6400.n44 VSS 0.09838f
C612 a_14860_6400.n45 VSS 0.09838f
C613 a_14860_6400.n46 VSS 0.09838f
C614 a_14860_6400.n47 VSS 0.09838f
C615 a_14860_6400.n48 VSS 0.09838f
C616 a_14860_6400.n49 VSS 0.09838f
C617 a_14860_6400.n50 VSS 0.09838f
C618 a_14860_6400.n51 VSS 0.0638f
C619 a_14860_6400.n52 VSS 0.09838f
C620 a_14860_6400.n53 VSS 0.0638f
C621 a_14860_6400.n54 VSS 0.09838f
C622 a_14860_6400.n55 VSS 0.0638f
C623 a_14860_6400.n56 VSS 0.09838f
C624 a_14860_6400.n57 VSS 0.09178f
C625 a_14860_6400.n58 VSS 0.18569f
C626 a_14860_6400.n59 VSS 0.09838f
C627 a_14860_6400.n60 VSS 0.09838f
C628 a_14860_6400.n61 VSS 0.09838f
C629 a_14860_6400.n62 VSS 0.0638f
C630 a_14860_6400.n63 VSS 0.0638f
C631 a_14860_6400.n64 VSS 0.0638f
C632 a_14860_6400.n65 VSS 0.09838f
C633 a_14860_6400.n66 VSS 0.09838f
C634 a_14860_6400.n67 VSS 0.09838f
C635 a_14860_6400.n68 VSS 0.0638f
C636 a_14860_6400.n69 VSS 0.0638f
C637 a_14860_6400.n70 VSS 0.0638f
C638 a_14860_6400.n71 VSS 0.09838f
C639 a_14860_6400.n72 VSS 0.09838f
C640 a_14860_6400.n73 VSS 0.09838f
C641 a_14860_6400.n74 VSS 0.0638f
C642 a_14860_6400.n75 VSS 0.0638f
C643 a_14860_6400.n76 VSS 0.0638f
C644 a_14860_6400.n77 VSS 0.09838f
C645 a_14860_6400.n78 VSS 0.09838f
C646 a_14860_6400.n79 VSS 0.09838f
C647 a_14860_6400.n80 VSS 0.05375f
C648 a_14860_6400.n81 VSS 0.97413f
C649 a_14860_6400.n82 VSS 0.05375f
C650 a_14860_6400.n83 VSS 0.0638f
C651 a_14860_6400.n84 VSS 0.0638f
C652 a_14860_6400.n85 VSS 0.0638f
C653 a_14860_6400.n86 VSS 0.0638f
C654 a_14860_6400.n87 VSS 0.0638f
C655 a_14860_6400.n88 VSS 0.0638f
C656 a_14860_6400.n89 VSS 0.0638f
C657 a_14860_6400.n90 VSS 0.0638f
C658 a_14860_6400.n91 VSS 0.0638f
C659 a_14860_6400.n92 VSS 0.0638f
C660 a_14860_6400.n93 VSS 0.0638f
C661 a_14860_6400.n94 VSS 0.0638f
C662 a_14860_6400.n95 VSS 0.18569f
C663 a_14860_6400.n96 VSS 0.09178f
C664 a_14860_6400.n97 VSS 0.09838f
C665 a_14860_6400.n98 VSS 0.09838f
C666 a_14860_6400.n99 VSS 0.09838f
C667 a_14860_6400.n100 VSS 0.09838f
C668 a_14860_6400.n101 VSS 0.09838f
C669 a_14860_6400.n102 VSS 0.09838f
C670 a_14860_6400.n103 VSS 0.09838f
C671 a_14860_6400.n104 VSS 0.09838f
C672 a_14860_6400.n105 VSS 0.09838f
C673 a_14860_6400.n106 VSS 0.09838f
C674 a_14860_6400.n107 VSS 0.09838f
C675 a_14860_6400.n108 VSS 0.09838f
C676 a_14860_6400.n109 VSS 0.09838f
C677 a_14860_6400.n110 VSS 0.09838f
C678 a_14860_6400.n111 VSS 0.09838f
C679 a_14860_6400.n112 VSS 0.0638f
C680 a_14860_6400.n113 VSS 0.09838f
C681 a_14860_6400.n114 VSS 0.0638f
C682 a_14860_6400.n115 VSS 0.09838f
C683 a_14860_6400.n116 VSS 0.0638f
C684 a_14860_6400.n117 VSS 0.09838f
C685 a_14860_6400.n118 VSS 0.09178f
C686 a_14860_6400.n119 VSS 0.18569f
C687 a_14860_6400.n120 VSS 0.09838f
C688 a_14860_6400.n121 VSS 0.09838f
C689 a_14860_6400.n122 VSS 0.09838f
C690 a_14860_6400.n123 VSS 0.0638f
C691 a_14860_6400.n124 VSS 0.0638f
C692 a_14860_6400.n125 VSS 0.0638f
C693 a_14860_6400.n126 VSS 0.09838f
C694 a_14860_6400.n127 VSS 0.09838f
C695 a_14860_6400.n128 VSS 0.09838f
C696 a_14860_6400.n129 VSS 0.0638f
C697 a_14860_6400.n130 VSS 0.0638f
C698 a_14860_6400.n131 VSS 0.0638f
C699 a_14860_6400.n132 VSS 0.09838f
C700 a_14860_6400.n133 VSS 0.09838f
C701 a_14860_6400.n134 VSS 0.09838f
C702 a_14860_6400.n135 VSS 0.0638f
C703 a_14860_6400.n136 VSS 0.0638f
C704 a_14860_6400.n137 VSS 0.0638f
C705 a_14860_6400.n138 VSS 0.09838f
C706 a_14860_6400.n139 VSS 0.09838f
C707 a_14860_6400.n140 VSS 0.09838f
C708 a_14860_6400.n141 VSS 0.05375f
C709 a_14860_6400.n142 VSS 0.82184f
C710 a_14860_6400.n143 VSS 3.0316f
C711 a_14860_6400.n144 VSS 1.8379f
C712 a_14860_6400.t29 VSS 0.80543f
C713 a_14860_6400.n145 VSS 0.23407f
C714 a_14860_6400.t19 VSS 0.20597f
C715 a_14860_6400.t28 VSS 0.20597f
C716 a_14860_6400.n146 VSS 0.57718f
C717 a_14860_6400.n147 VSS 0.17113f
C718 a_14860_6400.t5 VSS 0.20597f
C719 a_14860_6400.t18 VSS 0.20597f
C720 a_14860_6400.n148 VSS 0.57718f
C721 a_14860_6400.n149 VSS 0.17113f
C722 a_14860_6400.t1 VSS 0.20597f
C723 a_14860_6400.t4 VSS 0.20597f
C724 a_14860_6400.n150 VSS 0.57718f
C725 a_14860_6400.n151 VSS 0.17113f
C726 a_14860_6400.n152 VSS 0.17113f
C727 a_14860_6400.n153 VSS 0.57718f
C728 a_14860_6400.t0 VSS 0.20597f
C729 VSS.t271 VSS 0.09549f
C730 VSS.t281 VSS 0.09732f
C731 VSS.t267 VSS 0.09549f
C732 VSS.t269 VSS 0.09549f
C733 VSS.t237 VSS 0.09549f
C734 VSS.t239 VSS 0.09549f
C735 VSS.t217 VSS 0.09549f
C736 VSS.t235 VSS 0.09549f
C737 VSS.t213 VSS 0.09549f
C738 VSS.t215 VSS 0.09549f
C739 VSS.t297 VSS 0.09549f
C740 VSS.t299 VSS 0.09549f
C741 VSS.t287 VSS 0.09549f
C742 VSS.t295 VSS 0.09549f
C743 VSS.t283 VSS 0.09549f
C744 VSS.t285 VSS 0.09549f
C745 VSS.t275 VSS 0.09549f
C746 VSS.t277 VSS 0.09549f
C747 VSS.t231 VSS 0.09549f
C748 VSS.t273 VSS 0.09549f
C749 VSS.t227 VSS 0.09549f
C750 VSS.t229 VSS 0.09549f
C751 VSS.t221 VSS 0.09549f
C752 VSS.t223 VSS 0.09549f
C753 VSS.t305 VSS 0.09549f
C754 VSS.t219 VSS 0.09549f
C755 VSS.t301 VSS 0.09549f
C756 VSS.t303 VSS 0.09549f
C757 VSS.t291 VSS 0.09549f
C758 VSS.t293 VSS 0.09549f
C759 VSS.t279 VSS 0.09732f
C760 VSS.t289 VSS 0.09549f
C761 VSS.t255 VSS 0.09364f
C762 VSS.t257 VSS 0.09543f
C763 VSS.t141 VSS 0.09364f
C764 VSS.t143 VSS 0.09364f
C765 VSS.t41 VSS 0.09364f
C766 VSS.t43 VSS 0.09364f
C767 VSS.t1 VSS 0.09364f
C768 VSS.t3 VSS 0.09364f
C769 VSS.t147 VSS 0.09364f
C770 VSS.t149 VSS 0.09364f
C771 VSS.t21 VSS 0.09364f
C772 VSS.t23 VSS 0.09364f
C773 VSS.t75 VSS 0.09364f
C774 VSS.t77 VSS 0.09364f
C775 VSS.t109 VSS 0.09543f
C776 VSS.t111 VSS 0.09364f
C777 VSS.t261 VSS 0.09989f
C778 VSS.t211 VSS 0.10181f
C779 VSS.t205 VSS 0.09989f
C780 VSS.t225 VSS 0.09989f
C781 VSS.t209 VSS 0.09989f
C782 VSS.t207 VSS 0.09989f
C783 VSS.t233 VSS 0.10181f
C784 VSS.t259 VSS 0.09989f
C785 VSS.t113 VSS 0.09566f
C786 VSS.t307 VSS 0.09749f
C787 VSS.t145 VSS 0.09566f
C788 VSS.t53 VSS 0.09566f
C789 VSS.t151 VSS 0.09566f
C790 VSS.t65 VSS 0.09566f
C791 VSS.t57 VSS 0.09749f
C792 VSS.t67 VSS 0.09566f
C793 VSS.t165 VSS 0.07089f
C794 VSS.t157 VSS 0.07225f
C795 VSS.t171 VSS 0.07089f
C796 VSS.t169 VSS 0.07089f
C797 VSS.t173 VSS 0.07225f
C798 VSS.t167 VSS 0.07089f
C799 VSS.t95 VSS 0.06306f
C800 VSS.t93 VSS 0.06427f
C801 VSS.t99 VSS 0.06427f
C802 VSS.t97 VSS 0.06306f
C803 VSS.t161 VSS 0.07089f
C804 VSS.t163 VSS 0.07225f
C805 VSS.t155 VSS 0.07225f
C806 VSS.t159 VSS 0.07089f
C807 VSS.t181 VSS 0.06971f
C808 VSS.t185 VSS 0.07105f
C809 VSS.t187 VSS 0.07105f
C810 VSS.t179 VSS 0.06971f
C811 VSS.t79 VSS 0.09549f
C812 VSS.t25 VSS 0.09732f
C813 VSS.t131 VSS 0.09549f
C814 VSS.t119 VSS 0.09549f
C815 VSS.t241 VSS 0.09549f
C816 VSS.t121 VSS 0.09549f
C817 VSS.t83 VSS 0.09549f
C818 VSS.t27 VSS 0.09549f
C819 VSS.t177 VSS 0.09549f
C820 VSS.t81 VSS 0.09549f
C821 VSS.t135 VSS 0.09549f
C822 VSS.t175 VSS 0.09549f
C823 VSS.t139 VSS 0.09549f
C824 VSS.t133 VSS 0.09549f
C825 VSS.t201 VSS 0.09549f
C826 VSS.t137 VSS 0.09549f
C827 VSS.t31 VSS 0.09549f
C828 VSS.t199 VSS 0.09549f
C829 VSS.t87 VSS 0.09549f
C830 VSS.t29 VSS 0.09549f
C831 VSS.t47 VSS 0.09549f
C832 VSS.t85 VSS 0.09549f
C833 VSS.t7 VSS 0.09549f
C834 VSS.t45 VSS 0.09549f
C835 VSS.t35 VSS 0.09549f
C836 VSS.t5 VSS 0.09549f
C837 VSS.t91 VSS 0.09549f
C838 VSS.t33 VSS 0.09549f
C839 VSS.t51 VSS 0.09549f
C840 VSS.t89 VSS 0.09549f
C841 VSS.t9 VSS 0.09732f
C842 VSS.t49 VSS 0.09549f
C843 VSS.t247 VSS 0.06306f
C844 VSS.t243 VSS 0.06427f
C845 VSS.t245 VSS 0.06427f
C846 VSS.t249 VSS 0.06306f
C847 VSS.t189 VSS 0.06971f
C848 VSS.t183 VSS 0.07105f
C849 VSS.t195 VSS 0.06971f
C850 VSS.t193 VSS 0.06971f
C851 VSS.t197 VSS 0.07105f
C852 VSS.t191 VSS 0.06971f
C853 VSS.t127 VSS 0.09566f
C854 VSS.t129 VSS 0.09749f
C855 VSS.t115 VSS 0.09566f
C856 VSS.t117 VSS 0.09566f
C857 VSS.t63 VSS 0.09566f
C858 VSS.t17 VSS 0.09566f
C859 VSS.t19 VSS 0.09749f
C860 VSS.t55 VSS 0.09566f
C861 VSS.t61 VSS 0.09989f
C862 VSS.t73 VSS 0.10181f
C863 VSS.t39 VSS 0.09989f
C864 VSS.t59 VSS 0.09989f
C865 VSS.t125 VSS 0.09989f
C866 VSS.t37 VSS 0.09989f
C867 VSS.t15 VSS 0.10181f
C868 VSS.t123 VSS 0.09989f
C869 VSS.t253 VSS 0.09364f
C870 VSS.t153 VSS 0.09543f
C871 VSS.t13 VSS 0.09364f
C872 VSS.t251 VSS 0.09364f
C873 VSS.t71 VSS 0.09364f
C874 VSS.t11 VSS 0.09364f
C875 VSS.t311 VSS 0.09364f
C876 VSS.t69 VSS 0.09364f
C877 VSS.t103 VSS 0.09364f
C878 VSS.t309 VSS 0.09364f
C879 VSS.t265 VSS 0.09364f
C880 VSS.t101 VSS 0.09364f
C881 VSS.t107 VSS 0.09364f
C882 VSS.t263 VSS 0.09364f
C883 VSS.t203 VSS 0.09543f
C884 VSS.t105 VSS 0.09364f
C885 VDD.n1 VSS 1.25444f
C886 VDD.n2 VSS 4.39472f
C887 VDD.t275 VSS 0.10426f
C888 VDD.t295 VSS 0.10609f
C889 VDD.n3 VSS 0.04576f
C890 VDD.t287 VSS 0.10426f
C891 VDD.t273 VSS 0.10426f
C892 VDD.n4 VSS 0.04541f
C893 VDD.n5 VSS 0.02301f
C894 VDD.t279 VSS 0.10426f
C895 VDD.t285 VSS 0.10426f
C896 VDD.n6 VSS 0.04541f
C897 VDD.n7 VSS 0.01303f
C898 VDD.t223 VSS 0.10426f
C899 VDD.t277 VSS 0.10426f
C900 VDD.n8 VSS 0.04541f
C901 VDD.n9 VSS 0.01303f
C902 VDD.t251 VSS 0.10426f
C903 VDD.t221 VSS 0.10426f
C904 VDD.n10 VSS 0.04541f
C905 VDD.n11 VSS 0.01303f
C906 VDD.t239 VSS 0.10426f
C907 VDD.t249 VSS 0.10426f
C908 VDD.n12 VSS 0.04541f
C909 VDD.n13 VSS 0.01303f
C910 VDD.t231 VSS 0.10426f
C911 VDD.t237 VSS 0.10426f
C912 VDD.n14 VSS 0.04541f
C913 VDD.n15 VSS 0.01303f
C914 VDD.t299 VSS 0.10426f
C915 VDD.t229 VSS 0.10426f
C916 VDD.n16 VSS 0.04541f
C917 VDD.n17 VSS 0.01303f
C918 VDD.t291 VSS 0.10426f
C919 VDD.t297 VSS 0.10426f
C920 VDD.n18 VSS 0.04541f
C921 VDD.n19 VSS 0.01303f
C922 VDD.t283 VSS 0.10426f
C923 VDD.t289 VSS 0.10426f
C924 VDD.n20 VSS 0.04541f
C925 VDD.n21 VSS 0.01303f
C926 VDD.t227 VSS 0.10426f
C927 VDD.t281 VSS 0.10426f
C928 VDD.n22 VSS 0.04541f
C929 VDD.n23 VSS 0.01303f
C930 VDD.t247 VSS 0.10426f
C931 VDD.t225 VSS 0.10426f
C932 VDD.n24 VSS 0.04541f
C933 VDD.n25 VSS 0.01303f
C934 VDD.t243 VSS 0.10426f
C935 VDD.t245 VSS 0.10426f
C936 VDD.n26 VSS 0.04541f
C937 VDD.n27 VSS 0.01303f
C938 VDD.t235 VSS 0.10426f
C939 VDD.t241 VSS 0.10426f
C940 VDD.n28 VSS 0.04541f
C941 VDD.n29 VSS 0.01303f
C942 VDD.t303 VSS 0.10426f
C943 VDD.t233 VSS 0.10426f
C944 VDD.n30 VSS 0.04541f
C945 VDD.n31 VSS 0.01303f
C946 VDD.t293 VSS 0.10609f
C947 VDD.t301 VSS 0.10426f
C948 VDD.n32 VSS 0.04541f
C949 VDD.n33 VSS 0.08195f
C950 VDD.n34 VSS 1.02942f
C951 VDD.t292 VSS 2.5159f
C952 VDD.t300 VSS 0.12213f
C953 VDD.t302 VSS 0.12213f
C954 VDD.t232 VSS 0.12213f
C955 VDD.t234 VSS 0.12213f
C956 VDD.t240 VSS 0.12213f
C957 VDD.t242 VSS 0.12213f
C958 VDD.t244 VSS 0.12213f
C959 VDD.t246 VSS 0.12213f
C960 VDD.t224 VSS 0.12213f
C961 VDD.t226 VSS 0.12213f
C962 VDD.t280 VSS 0.12213f
C963 VDD.t282 VSS 0.12213f
C964 VDD.t288 VSS 0.12213f
C965 VDD.t290 VSS 0.12213f
C966 VDD.t296 VSS 0.12213f
C967 VDD.t298 VSS 0.12213f
C968 VDD.t228 VSS 0.12213f
C969 VDD.t230 VSS 0.12213f
C970 VDD.t236 VSS 0.12213f
C971 VDD.t238 VSS 0.12213f
C972 VDD.t248 VSS 0.12213f
C973 VDD.t250 VSS 0.12213f
C974 VDD.t220 VSS 0.12213f
C975 VDD.t222 VSS 0.12213f
C976 VDD.t276 VSS 0.12213f
C977 VDD.t278 VSS 0.12213f
C978 VDD.t284 VSS 0.12213f
C979 VDD.t286 VSS 0.12213f
C980 VDD.t272 VSS 0.12213f
C981 VDD.t274 VSS 0.12213f
C982 VDD.t294 VSS 0.36945f
C983 VDD.t178 VSS 0.68454f
C984 VDD.t174 VSS 0.12213f
C985 VDD.t180 VSS 0.12213f
C986 VDD.t176 VSS 0.68393f
C987 VDD.t78 VSS 0.68393f
C988 VDD.t82 VSS 0.12213f
C989 VDD.t84 VSS 0.12213f
C990 VDD.t80 VSS 0.68393f
C991 VDD.t182 VSS 0.68393f
C992 VDD.t184 VSS 0.12213f
C993 VDD.t188 VSS 0.12213f
C994 VDD.t190 VSS 0.12213f
C995 VDD.t186 VSS 0.12213f
C996 VDD.t192 VSS 0.68393f
C997 VDD.t18 VSS 0.68393f
C998 VDD.t54 VSS 0.12213f
C999 VDD.t16 VSS 0.12213f
C1000 VDD.t138 VSS 0.12213f
C1001 VDD.t8 VSS 0.12213f
C1002 VDD.t156 VSS 0.12213f
C1003 VDD.t262 VSS 0.12213f
C1004 VDD.t10 VSS 0.68393f
C1005 VDD.t32 VSS 0.68393f
C1006 VDD.t30 VSS 0.12213f
C1007 VDD.t214 VSS 0.12213f
C1008 VDD.t104 VSS 0.12213f
C1009 VDD.t128 VSS 0.12213f
C1010 VDD.t28 VSS 0.12213f
C1011 VDD.t34 VSS 0.12213f
C1012 VDD.t50 VSS 0.68393f
C1013 VDD.t122 VSS 0.68393f
C1014 VDD.t120 VSS 0.12213f
C1015 VDD.t266 VSS 0.12213f
C1016 VDD.t264 VSS 0.12213f
C1017 VDD.t136 VSS 0.12213f
C1018 VDD.t134 VSS 0.12213f
C1019 VDD.t146 VSS 0.12213f
C1020 VDD.t144 VSS 0.12213f
C1021 VDD.t92 VSS 0.12213f
C1022 VDD.t90 VSS 0.12213f
C1023 VDD.t96 VSS 0.12213f
C1024 VDD.t94 VSS 0.12213f
C1025 VDD.t310 VSS 0.12213f
C1026 VDD.t308 VSS 0.12213f
C1027 VDD.t154 VSS 0.12213f
C1028 VDD.t152 VSS 0.37555f
C1029 VDD.n35 VSS 0.63153f
C1030 VDD.n36 VSS 0.02507f
C1031 VDD.n37 VSS 0.04706f
C1032 VDD.t121 VSS 0.10241f
C1033 VDD.t123 VSS 0.10421f
C1034 VDD.n38 VSS 0.04576f
C1035 VDD.t265 VSS 0.10241f
C1036 VDD.t267 VSS 0.10241f
C1037 VDD.n39 VSS 0.04541f
C1038 VDD.n40 VSS 0.02301f
C1039 VDD.t135 VSS 0.10241f
C1040 VDD.t137 VSS 0.10241f
C1041 VDD.n41 VSS 0.04541f
C1042 VDD.n42 VSS 0.01303f
C1043 VDD.t145 VSS 0.10241f
C1044 VDD.t147 VSS 0.10241f
C1045 VDD.n43 VSS 0.04541f
C1046 VDD.n44 VSS 0.01303f
C1047 VDD.t91 VSS 0.10241f
C1048 VDD.t93 VSS 0.10241f
C1049 VDD.n45 VSS 0.04541f
C1050 VDD.n46 VSS 0.01303f
C1051 VDD.t95 VSS 0.10241f
C1052 VDD.t97 VSS 0.10241f
C1053 VDD.n47 VSS 0.04541f
C1054 VDD.n48 VSS 0.01303f
C1055 VDD.t309 VSS 0.10241f
C1056 VDD.t311 VSS 0.10241f
C1057 VDD.n49 VSS 0.04541f
C1058 VDD.n50 VSS 0.01303f
C1059 VDD.t153 VSS 0.10421f
C1060 VDD.t155 VSS 0.10241f
C1061 VDD.n51 VSS 0.04541f
C1062 VDD.n52 VSS 0.05086f
C1063 VDD.n53 VSS 0.41292f
C1064 VDD.t31 VSS 0.10866f
C1065 VDD.t33 VSS 0.11058f
C1066 VDD.n54 VSS 0.04576f
C1067 VDD.t105 VSS 0.10866f
C1068 VDD.t215 VSS 0.10866f
C1069 VDD.n55 VSS 0.04541f
C1070 VDD.n56 VSS 0.02301f
C1071 VDD.t29 VSS 0.10866f
C1072 VDD.t129 VSS 0.10866f
C1073 VDD.n57 VSS 0.04541f
C1074 VDD.n58 VSS 0.01303f
C1075 VDD.t51 VSS 0.11058f
C1076 VDD.t35 VSS 0.10866f
C1077 VDD.n59 VSS 0.04541f
C1078 VDD.n60 VSS 0.05086f
C1079 VDD.n61 VSS 0.60303f
C1080 VDD.t55 VSS 0.10443f
C1081 VDD.t19 VSS 0.10626f
C1082 VDD.n62 VSS 0.04576f
C1083 VDD.t139 VSS 0.10443f
C1084 VDD.t17 VSS 0.10443f
C1085 VDD.n63 VSS 0.04541f
C1086 VDD.n64 VSS 0.02301f
C1087 VDD.t157 VSS 0.10443f
C1088 VDD.t9 VSS 0.10443f
C1089 VDD.n65 VSS 0.04541f
C1090 VDD.n66 VSS 0.01303f
C1091 VDD.t11 VSS 0.10626f
C1092 VDD.t263 VSS 0.10443f
C1093 VDD.n67 VSS 0.04541f
C1094 VDD.n68 VSS 0.05086f
C1095 VDD.n69 VSS 0.49507f
C1096 VDD.t185 VSS 0.07966f
C1097 VDD.t183 VSS 0.08102f
C1098 VDD.n70 VSS 0.04576f
C1099 VDD.t191 VSS 0.07966f
C1100 VDD.t189 VSS 0.07966f
C1101 VDD.n71 VSS 0.04541f
C1102 VDD.n72 VSS 0.02301f
C1103 VDD.t193 VSS 0.08102f
C1104 VDD.t187 VSS 0.07966f
C1105 VDD.n73 VSS 0.04541f
C1106 VDD.n74 VSS 0.05086f
C1107 VDD.n75 VSS 0.46808f
C1108 VDD.t83 VSS 0.07183f
C1109 VDD.t79 VSS 0.07304f
C1110 VDD.n76 VSS 0.04576f
C1111 VDD.t81 VSS 0.07304f
C1112 VDD.t85 VSS 0.07183f
C1113 VDD.n77 VSS 0.04541f
C1114 VDD.n78 VSS 0.06084f
C1115 VDD.n79 VSS 0.4141f
C1116 VDD.t175 VSS 0.07966f
C1117 VDD.t179 VSS 0.08102f
C1118 VDD.n80 VSS 0.04576f
C1119 VDD.t177 VSS 0.08102f
C1120 VDD.t181 VSS 0.07966f
C1121 VDD.n81 VSS 0.04541f
C1122 VDD.n82 VSS 0.06084f
C1123 VDD.n83 VSS 0.38626f
C1124 VDD.n84 VSS 0.18235f
C1125 VDD.n85 VSS 2.37807f
C1126 VDD.n86 VSS 32.4756f
C1127 VDD.n87 VSS 68.811f
C1128 VDD.n88 VSS 1.25444f
C1129 VDD.n89 VSS 4.39472f
C1130 VDD.t103 VSS 0.10426f
C1131 VDD.t73 VSS 0.10609f
C1132 VDD.n90 VSS 0.04576f
C1133 VDD.t167 VSS 0.10426f
C1134 VDD.t169 VSS 0.10426f
C1135 VDD.n91 VSS 0.04541f
C1136 VDD.n92 VSS 0.02301f
C1137 VDD.t69 VSS 0.10426f
C1138 VDD.t165 VSS 0.10426f
C1139 VDD.n93 VSS 0.04541f
C1140 VDD.n94 VSS 0.01303f
C1141 VDD.t171 VSS 0.10426f
C1142 VDD.t219 VSS 0.10426f
C1143 VDD.n95 VSS 0.04541f
C1144 VDD.n96 VSS 0.01303f
C1145 VDD.t1 VSS 0.10426f
C1146 VDD.t253 VSS 0.10426f
C1147 VDD.n97 VSS 0.04541f
C1148 VDD.n98 VSS 0.01303f
C1149 VDD.t75 VSS 0.10426f
C1150 VDD.t57 VSS 0.10426f
C1151 VDD.n99 VSS 0.04541f
C1152 VDD.n100 VSS 0.01303f
C1153 VDD.t77 VSS 0.10426f
C1154 VDD.t173 VSS 0.10426f
C1155 VDD.n101 VSS 0.04541f
C1156 VDD.n102 VSS 0.01303f
C1157 VDD.t45 VSS 0.10426f
C1158 VDD.t217 VSS 0.10426f
C1159 VDD.n103 VSS 0.04541f
C1160 VDD.n104 VSS 0.01303f
C1161 VDD.t25 VSS 0.10426f
C1162 VDD.t3 VSS 0.10426f
C1163 VDD.n105 VSS 0.04541f
C1164 VDD.n106 VSS 0.01303f
C1165 VDD.t47 VSS 0.10426f
C1166 VDD.t61 VSS 0.10426f
C1167 VDD.n107 VSS 0.04541f
C1168 VDD.n108 VSS 0.01303f
C1169 VDD.t27 VSS 0.10426f
C1170 VDD.t5 VSS 0.10426f
C1171 VDD.n109 VSS 0.04541f
C1172 VDD.n110 VSS 0.01303f
C1173 VDD.t111 VSS 0.10426f
C1174 VDD.t63 VSS 0.10426f
C1175 VDD.n111 VSS 0.04541f
C1176 VDD.n112 VSS 0.01303f
C1177 VDD.t99 VSS 0.10426f
C1178 VDD.t131 VSS 0.10426f
C1179 VDD.n113 VSS 0.04541f
C1180 VDD.n114 VSS 0.01303f
C1181 VDD.t133 VSS 0.10426f
C1182 VDD.t125 VSS 0.10426f
C1183 VDD.n115 VSS 0.04541f
C1184 VDD.n116 VSS 0.01303f
C1185 VDD.t127 VSS 0.10426f
C1186 VDD.t71 VSS 0.10426f
C1187 VDD.n117 VSS 0.04541f
C1188 VDD.n118 VSS 0.01303f
C1189 VDD.t7 VSS 0.10609f
C1190 VDD.t49 VSS 0.10426f
C1191 VDD.n119 VSS 0.04541f
C1192 VDD.n120 VSS 0.08195f
C1193 VDD.n121 VSS 1.02942f
C1194 VDD.t6 VSS 2.5159f
C1195 VDD.t48 VSS 0.12213f
C1196 VDD.t126 VSS 0.12213f
C1197 VDD.t70 VSS 0.12213f
C1198 VDD.t132 VSS 0.12213f
C1199 VDD.t124 VSS 0.12213f
C1200 VDD.t98 VSS 0.12213f
C1201 VDD.t130 VSS 0.12213f
C1202 VDD.t110 VSS 0.12213f
C1203 VDD.t62 VSS 0.12213f
C1204 VDD.t26 VSS 0.12213f
C1205 VDD.t4 VSS 0.12213f
C1206 VDD.t46 VSS 0.12213f
C1207 VDD.t60 VSS 0.12213f
C1208 VDD.t24 VSS 0.12213f
C1209 VDD.t2 VSS 0.12213f
C1210 VDD.t44 VSS 0.12213f
C1211 VDD.t216 VSS 0.12213f
C1212 VDD.t76 VSS 0.12213f
C1213 VDD.t172 VSS 0.12213f
C1214 VDD.t74 VSS 0.12213f
C1215 VDD.t56 VSS 0.12213f
C1216 VDD.t0 VSS 0.12213f
C1217 VDD.t252 VSS 0.12213f
C1218 VDD.t170 VSS 0.12213f
C1219 VDD.t218 VSS 0.12213f
C1220 VDD.t68 VSS 0.12213f
C1221 VDD.t164 VSS 0.12213f
C1222 VDD.t166 VSS 0.12213f
C1223 VDD.t168 VSS 0.12213f
C1224 VDD.t102 VSS 0.12213f
C1225 VDD.t72 VSS 0.36945f
C1226 VDD.t198 VSS 0.68454f
C1227 VDD.t196 VSS 0.12213f
C1228 VDD.t200 VSS 0.12213f
C1229 VDD.t194 VSS 0.68393f
C1230 VDD.t254 VSS 0.68393f
C1231 VDD.t256 VSS 0.12213f
C1232 VDD.t258 VSS 0.12213f
C1233 VDD.t260 VSS 0.68393f
C1234 VDD.t202 VSS 0.68393f
C1235 VDD.t204 VSS 0.12213f
C1236 VDD.t206 VSS 0.12213f
C1237 VDD.t210 VSS 0.12213f
C1238 VDD.t208 VSS 0.12213f
C1239 VDD.t212 VSS 0.68393f
C1240 VDD.t22 VSS 0.68393f
C1241 VDD.t20 VSS 0.12213f
C1242 VDD.t42 VSS 0.12213f
C1243 VDD.t40 VSS 0.12213f
C1244 VDD.t66 VSS 0.12213f
C1245 VDD.t64 VSS 0.12213f
C1246 VDD.t118 VSS 0.12213f
C1247 VDD.t116 VSS 0.68393f
C1248 VDD.t52 VSS 0.68393f
C1249 VDD.t38 VSS 0.12213f
C1250 VDD.t36 VSS 0.12213f
C1251 VDD.t114 VSS 0.12213f
C1252 VDD.t112 VSS 0.12213f
C1253 VDD.t14 VSS 0.12213f
C1254 VDD.t12 VSS 0.12213f
C1255 VDD.t58 VSS 0.68393f
C1256 VDD.t100 VSS 0.68393f
C1257 VDD.t160 VSS 0.12213f
C1258 VDD.t158 VSS 0.12213f
C1259 VDD.t270 VSS 0.12213f
C1260 VDD.t268 VSS 0.12213f
C1261 VDD.t142 VSS 0.12213f
C1262 VDD.t140 VSS 0.12213f
C1263 VDD.t150 VSS 0.12213f
C1264 VDD.t148 VSS 0.12213f
C1265 VDD.t306 VSS 0.12213f
C1266 VDD.t304 VSS 0.12213f
C1267 VDD.t88 VSS 0.12213f
C1268 VDD.t86 VSS 0.12213f
C1269 VDD.t108 VSS 0.12213f
C1270 VDD.t106 VSS 0.12213f
C1271 VDD.t162 VSS 0.37555f
C1272 VDD.n122 VSS 0.63153f
C1273 VDD.n123 VSS 0.02507f
C1274 VDD.n124 VSS 0.04706f
C1275 VDD.t161 VSS 0.10241f
C1276 VDD.t101 VSS 0.10421f
C1277 VDD.n125 VSS 0.04576f
C1278 VDD.t271 VSS 0.10241f
C1279 VDD.t159 VSS 0.10241f
C1280 VDD.n126 VSS 0.04541f
C1281 VDD.n127 VSS 0.02301f
C1282 VDD.t143 VSS 0.10241f
C1283 VDD.t269 VSS 0.10241f
C1284 VDD.n128 VSS 0.04541f
C1285 VDD.n129 VSS 0.01303f
C1286 VDD.t151 VSS 0.10241f
C1287 VDD.t141 VSS 0.10241f
C1288 VDD.n130 VSS 0.04541f
C1289 VDD.n131 VSS 0.01303f
C1290 VDD.t307 VSS 0.10241f
C1291 VDD.t149 VSS 0.10241f
C1292 VDD.n132 VSS 0.04541f
C1293 VDD.n133 VSS 0.01303f
C1294 VDD.t89 VSS 0.10241f
C1295 VDD.t305 VSS 0.10241f
C1296 VDD.n134 VSS 0.04541f
C1297 VDD.n135 VSS 0.01303f
C1298 VDD.t109 VSS 0.10241f
C1299 VDD.t87 VSS 0.10241f
C1300 VDD.n136 VSS 0.04541f
C1301 VDD.n137 VSS 0.01303f
C1302 VDD.t163 VSS 0.10421f
C1303 VDD.t107 VSS 0.10241f
C1304 VDD.n138 VSS 0.04541f
C1305 VDD.n139 VSS 0.05086f
C1306 VDD.n140 VSS 0.41292f
C1307 VDD.t39 VSS 0.10866f
C1308 VDD.t53 VSS 0.11058f
C1309 VDD.n141 VSS 0.04576f
C1310 VDD.t115 VSS 0.10866f
C1311 VDD.t37 VSS 0.10866f
C1312 VDD.n142 VSS 0.04541f
C1313 VDD.n143 VSS 0.02301f
C1314 VDD.t15 VSS 0.10866f
C1315 VDD.t113 VSS 0.10866f
C1316 VDD.n144 VSS 0.04541f
C1317 VDD.n145 VSS 0.01303f
C1318 VDD.t59 VSS 0.11058f
C1319 VDD.t13 VSS 0.10866f
C1320 VDD.n146 VSS 0.04541f
C1321 VDD.n147 VSS 0.05086f
C1322 VDD.n148 VSS 0.60303f
C1323 VDD.t21 VSS 0.10443f
C1324 VDD.t23 VSS 0.10626f
C1325 VDD.n149 VSS 0.04576f
C1326 VDD.t41 VSS 0.10443f
C1327 VDD.t43 VSS 0.10443f
C1328 VDD.n150 VSS 0.04541f
C1329 VDD.n151 VSS 0.02301f
C1330 VDD.t65 VSS 0.10443f
C1331 VDD.t67 VSS 0.10443f
C1332 VDD.n152 VSS 0.04541f
C1333 VDD.n153 VSS 0.01303f
C1334 VDD.t117 VSS 0.10626f
C1335 VDD.t119 VSS 0.10443f
C1336 VDD.n154 VSS 0.04541f
C1337 VDD.n155 VSS 0.05086f
C1338 VDD.n156 VSS 0.49507f
C1339 VDD.t205 VSS 0.07848f
C1340 VDD.t203 VSS 0.07982f
C1341 VDD.n157 VSS 0.04576f
C1342 VDD.t211 VSS 0.07848f
C1343 VDD.t207 VSS 0.07848f
C1344 VDD.n158 VSS 0.04541f
C1345 VDD.n159 VSS 0.02301f
C1346 VDD.t213 VSS 0.07982f
C1347 VDD.t209 VSS 0.07848f
C1348 VDD.n160 VSS 0.04541f
C1349 VDD.n161 VSS 0.05086f
C1350 VDD.n162 VSS 0.46808f
C1351 VDD.t257 VSS 0.07183f
C1352 VDD.t255 VSS 0.07304f
C1353 VDD.n163 VSS 0.04576f
C1354 VDD.t261 VSS 0.07304f
C1355 VDD.t259 VSS 0.07183f
C1356 VDD.n164 VSS 0.04541f
C1357 VDD.n165 VSS 0.06084f
C1358 VDD.n166 VSS 0.4141f
C1359 VDD.t197 VSS 0.07848f
C1360 VDD.t199 VSS 0.07982f
C1361 VDD.n167 VSS 0.04576f
C1362 VDD.t195 VSS 0.07982f
C1363 VDD.t201 VSS 0.07848f
C1364 VDD.n168 VSS 0.04541f
C1365 VDD.n169 VSS 0.06084f
C1366 VDD.n170 VSS 0.38626f
C1367 VDD.n171 VSS 0.18235f
C1368 VDD.n172 VSS 2.37807f
C1369 VDD.n173 VSS 32.0335f
C1370 VDD.n174 VSS 69.25311f
C1371 VDD.n176 VSS 0.01219f
C1372 CLKN_HB.n0 VSS 0.12823f
C1373 CLKN_HB.n1 VSS 0.06701f
C1374 CLKN_HB.n2 VSS 0.07182f
C1375 CLKN_HB.n3 VSS 0.06701f
C1376 CLKN_HB.n4 VSS 0.07182f
C1377 CLKN_HB.n5 VSS 0.07182f
C1378 CLKN_HB.n6 VSS 0.07182f
C1379 CLKN_HB.n7 VSS 0.12823f
C1380 CLKN_HB.n8 VSS 0.19164f
C1381 CLKN_HB.n9 VSS 0.12823f
C1382 CLKN_HB.n10 VSS 0.06701f
C1383 CLKN_HB.n11 VSS 0.07182f
C1384 CLKN_HB.n12 VSS 0.06701f
C1385 CLKN_HB.n13 VSS 0.07182f
C1386 CLKN_HB.n14 VSS 0.07182f
C1387 CLKN_HB.n15 VSS 0.07182f
C1388 CLKN_HB.n16 VSS 0.12823f
C1389 CLKN_HB.n17 VSS 0.12494f
C1390 CLKN_HB.n18 VSS 0.91572f
C1391 CLKN_HB.n19 VSS 0.06606f
C1392 CLKN_HB.n20 VSS 0.07182f
C1393 CLKN_HB.n21 VSS 0.07182f
C1394 CLKN_HB.n22 VSS 0.06606f
C1395 CLKN_HB.n23 VSS 0.31529f
C1396 CLKN_HB.n24 VSS 0.06606f
C1397 CLKN_HB.n25 VSS 0.07182f
C1398 CLKN_HB.n26 VSS 0.07182f
C1399 CLKN_HB.n27 VSS 0.06606f
C1400 CLKN_HB.n28 VSS 0.25482f
C1401 CLKN_HB.n29 VSS 0.65084f
C1402 CLKN_HB.n30 VSS 1.26691f
C1403 CLKN_H.n0 VSS 0.05975f
C1404 CLKN_H.n1 VSS 0.06497f
C1405 CLKN_H.n2 VSS 0.06497f
C1406 CLKN_H.n3 VSS 0.05975f
C1407 CLKN_H.n4 VSS 0.28519f
C1408 CLKN_H.n5 VSS 0.05975f
C1409 CLKN_H.n6 VSS 0.06497f
C1410 CLKN_H.n7 VSS 0.06497f
C1411 CLKN_H.n8 VSS 0.05975f
C1412 CLKN_H.n9 VSS 0.23049f
C1413 CLKN_H.n10 VSS 1.74315f
C1414 O_CAPTURE_CLKB.t12 VSS 1.05668f
C1415 O_CAPTURE_CLKB.t13 VSS 0.24602f
C1416 O_CAPTURE_CLKB.t8 VSS 0.24602f
C1417 O_CAPTURE_CLKB.n0 VSS 0.7783f
C1418 O_CAPTURE_CLKB.n1 VSS 0.42781f
C1419 O_CAPTURE_CLKB.t9 VSS 0.24602f
C1420 O_CAPTURE_CLKB.t4 VSS 0.24602f
C1421 O_CAPTURE_CLKB.n2 VSS 0.7783f
C1422 O_CAPTURE_CLKB.n3 VSS 0.22332f
C1423 O_CAPTURE_CLKB.t5 VSS 0.24602f
C1424 O_CAPTURE_CLKB.t0 VSS 0.24602f
C1425 O_CAPTURE_CLKB.n4 VSS 0.7783f
C1426 O_CAPTURE_CLKB.n5 VSS 0.22332f
C1427 O_CAPTURE_CLKB.t1 VSS 1.04969f
C1428 O_CAPTURE_CLKB.n6 VSS 0.46205f
C1429 O_CAPTURE_CLKB.t3 VSS 1.05482f
C1430 O_CAPTURE_CLKB.t6 VSS 0.24602f
C1431 O_CAPTURE_CLKB.t7 VSS 0.24602f
C1432 O_CAPTURE_CLKB.n7 VSS 0.77256f
C1433 O_CAPTURE_CLKB.n8 VSS 0.4354f
C1434 O_CAPTURE_CLKB.t2 VSS 0.24602f
C1435 O_CAPTURE_CLKB.t10 VSS 0.24602f
C1436 O_CAPTURE_CLKB.n9 VSS 0.77256f
C1437 O_CAPTURE_CLKB.n10 VSS 0.22906f
C1438 O_CAPTURE_CLKB.t11 VSS 0.24602f
C1439 O_CAPTURE_CLKB.t14 VSS 0.24602f
C1440 O_CAPTURE_CLKB.n11 VSS 0.77256f
C1441 O_CAPTURE_CLKB.n12 VSS 0.22906f
C1442 O_CAPTURE_CLKB.t15 VSS 1.04782f
C1443 O_CAPTURE_CLKB.n13 VSS 0.3133f
C1444 O_CAPTURE_CLKB.n14 VSS 1.00544f
C1445 O_CAPTURE_CLK.t11 VSS 1.02124f
C1446 O_CAPTURE_CLK.t0 VSS 0.24402f
C1447 O_CAPTURE_CLK.t1 VSS 0.24402f
C1448 O_CAPTURE_CLK.n0 VSS 0.74604f
C1449 O_CAPTURE_CLK.n1 VSS 0.41008f
C1450 O_CAPTURE_CLK.t12 VSS 0.24402f
C1451 O_CAPTURE_CLK.t13 VSS 0.24402f
C1452 O_CAPTURE_CLK.n2 VSS 0.74604f
C1453 O_CAPTURE_CLK.n3 VSS 0.21407f
C1454 O_CAPTURE_CLK.t3 VSS 0.24402f
C1455 O_CAPTURE_CLK.t4 VSS 0.24402f
C1456 O_CAPTURE_CLK.n4 VSS 0.74604f
C1457 O_CAPTURE_CLK.n5 VSS 0.21407f
C1458 O_CAPTURE_CLK.t7 VSS 1.01454f
C1459 O_CAPTURE_CLK.n6 VSS 0.4429f
C1460 O_CAPTURE_CLK.t2 VSS 1.01946f
C1461 O_CAPTURE_CLK.t14 VSS 0.24402f
C1462 O_CAPTURE_CLK.t15 VSS 0.24402f
C1463 O_CAPTURE_CLK.n7 VSS 0.74054f
C1464 O_CAPTURE_CLK.n8 VSS 0.41736f
C1465 O_CAPTURE_CLK.t5 VSS 0.24402f
C1466 O_CAPTURE_CLK.t6 VSS 0.24402f
C1467 O_CAPTURE_CLK.n9 VSS 0.74054f
C1468 O_CAPTURE_CLK.n10 VSS 0.21957f
C1469 O_CAPTURE_CLK.t8 VSS 0.24402f
C1470 O_CAPTURE_CLK.t9 VSS 0.24402f
C1471 O_CAPTURE_CLK.n11 VSS 0.74054f
C1472 O_CAPTURE_CLK.n12 VSS 0.21957f
C1473 O_CAPTURE_CLK.t10 VSS 1.01275f
C1474 O_CAPTURE_CLK.n13 VSS 0.30032f
C1475 O_CAPTURE_CLK.n14 VSS 1.53502f
C1476 O_SENSE.t3 VSS 1.10169f
C1477 O_SENSE.t17 VSS 0.25293f
C1478 O_SENSE.t42 VSS 0.25293f
C1479 O_SENSE.n0 VSS 0.81497f
C1480 O_SENSE.n1 VSS 0.44796f
C1481 O_SENSE.t33 VSS 0.25293f
C1482 O_SENSE.t45 VSS 0.25293f
C1483 O_SENSE.n2 VSS 0.81497f
C1484 O_SENSE.n3 VSS 0.23385f
C1485 O_SENSE.t41 VSS 0.25293f
C1486 O_SENSE.t37 VSS 0.25293f
C1487 O_SENSE.n4 VSS 0.81497f
C1488 O_SENSE.n5 VSS 0.23385f
C1489 O_SENSE.t44 VSS 0.25293f
C1490 O_SENSE.t40 VSS 0.25293f
C1491 O_SENSE.n6 VSS 0.81497f
C1492 O_SENSE.n7 VSS 0.23385f
C1493 O_SENSE.t24 VSS 0.25293f
C1494 O_SENSE.t8 VSS 0.25293f
C1495 O_SENSE.n8 VSS 0.81497f
C1496 O_SENSE.n9 VSS 0.23385f
C1497 O_SENSE.t2 VSS 0.25293f
C1498 O_SENSE.t16 VSS 0.25293f
C1499 O_SENSE.n10 VSS 0.81497f
C1500 O_SENSE.n11 VSS 0.23385f
C1501 O_SENSE.t23 VSS 0.25293f
C1502 O_SENSE.t7 VSS 0.25293f
C1503 O_SENSE.n12 VSS 0.81497f
C1504 O_SENSE.n13 VSS 0.23385f
C1505 O_SENSE.t1 VSS 0.25293f
C1506 O_SENSE.t15 VSS 0.25293f
C1507 O_SENSE.n14 VSS 0.81497f
C1508 O_SENSE.n15 VSS 0.23385f
C1509 O_SENSE.t58 VSS 0.25293f
C1510 O_SENSE.t36 VSS 0.25293f
C1511 O_SENSE.n16 VSS 0.81497f
C1512 O_SENSE.n17 VSS 0.23385f
C1513 O_SENSE.t55 VSS 0.25293f
C1514 O_SENSE.t35 VSS 0.25293f
C1515 O_SENSE.n18 VSS 0.81497f
C1516 O_SENSE.n19 VSS 0.23385f
C1517 O_SENSE.t22 VSS 0.25293f
C1518 O_SENSE.t0 VSS 0.25293f
C1519 O_SENSE.n20 VSS 0.81497f
C1520 O_SENSE.n21 VSS 0.23385f
C1521 O_SENSE.t62 VSS 0.25293f
C1522 O_SENSE.t54 VSS 0.25293f
C1523 O_SENSE.n22 VSS 0.81497f
C1524 O_SENSE.n23 VSS 0.23385f
C1525 O_SENSE.t61 VSS 0.25293f
C1526 O_SENSE.t32 VSS 0.25293f
C1527 O_SENSE.n24 VSS 0.81497f
C1528 O_SENSE.n25 VSS 0.23385f
C1529 O_SENSE.t51 VSS 0.25293f
C1530 O_SENSE.t52 VSS 0.25293f
C1531 O_SENSE.n26 VSS 0.81497f
C1532 O_SENSE.n27 VSS 0.23385f
C1533 O_SENSE.t53 VSS 0.25293f
C1534 O_SENSE.t38 VSS 0.25293f
C1535 O_SENSE.n28 VSS 0.81497f
C1536 O_SENSE.n29 VSS 0.23385f
C1537 O_SENSE.t34 VSS 1.09438f
C1538 O_SENSE.n30 VSS 0.48382f
C1539 O_SENSE.t6 VSS 1.09975f
C1540 O_SENSE.t20 VSS 0.25293f
C1541 O_SENSE.t21 VSS 0.25293f
C1542 O_SENSE.n31 VSS 0.80896f
C1543 O_SENSE.n32 VSS 0.45592f
C1544 O_SENSE.t30 VSS 0.25293f
C1545 O_SENSE.t31 VSS 0.25293f
C1546 O_SENSE.n33 VSS 0.80896f
C1547 O_SENSE.n34 VSS 0.23986f
C1548 O_SENSE.t13 VSS 0.25293f
C1549 O_SENSE.t14 VSS 0.25293f
C1550 O_SENSE.n35 VSS 0.80896f
C1551 O_SENSE.n36 VSS 0.23986f
C1552 O_SENSE.t4 VSS 0.25293f
C1553 O_SENSE.t5 VSS 0.25293f
C1554 O_SENSE.n37 VSS 0.80896f
C1555 O_SENSE.n38 VSS 0.23986f
C1556 O_SENSE.t18 VSS 0.25293f
C1557 O_SENSE.t19 VSS 0.25293f
C1558 O_SENSE.n39 VSS 0.80896f
C1559 O_SENSE.n40 VSS 0.23986f
C1560 O_SENSE.t28 VSS 0.25293f
C1561 O_SENSE.t29 VSS 0.25293f
C1562 O_SENSE.n41 VSS 0.80896f
C1563 O_SENSE.n42 VSS 0.23986f
C1564 O_SENSE.t11 VSS 0.25293f
C1565 O_SENSE.t12 VSS 0.25293f
C1566 O_SENSE.n43 VSS 0.80896f
C1567 O_SENSE.n44 VSS 0.23986f
C1568 O_SENSE.t59 VSS 0.25293f
C1569 O_SENSE.t60 VSS 0.25293f
C1570 O_SENSE.n45 VSS 0.80896f
C1571 O_SENSE.n46 VSS 0.23986f
C1572 O_SENSE.t49 VSS 0.25293f
C1573 O_SENSE.t50 VSS 0.25293f
C1574 O_SENSE.n47 VSS 0.80896f
C1575 O_SENSE.n48 VSS 0.23986f
C1576 O_SENSE.t47 VSS 0.25293f
C1577 O_SENSE.t48 VSS 0.25293f
C1578 O_SENSE.n49 VSS 0.80896f
C1579 O_SENSE.n50 VSS 0.23986f
C1580 O_SENSE.t56 VSS 0.25293f
C1581 O_SENSE.t57 VSS 0.25293f
C1582 O_SENSE.n51 VSS 0.80896f
C1583 O_SENSE.n52 VSS 0.23986f
C1584 O_SENSE.t26 VSS 0.25293f
C1585 O_SENSE.t27 VSS 0.25293f
C1586 O_SENSE.n53 VSS 0.80896f
C1587 O_SENSE.n54 VSS 0.23986f
C1588 O_SENSE.t10 VSS 0.25293f
C1589 O_SENSE.t63 VSS 0.25293f
C1590 O_SENSE.n55 VSS 0.80896f
C1591 O_SENSE.n56 VSS 0.23986f
C1592 O_SENSE.t43 VSS 0.25293f
C1593 O_SENSE.t46 VSS 0.25293f
C1594 O_SENSE.n57 VSS 0.80896f
C1595 O_SENSE.n58 VSS 0.23986f
C1596 O_SENSE.t39 VSS 0.25293f
C1597 O_SENSE.t25 VSS 0.25293f
C1598 O_SENSE.n59 VSS 0.80896f
C1599 O_SENSE.n60 VSS 0.23986f
C1600 O_SENSE.t9 VSS 1.09242f
C1601 O_SENSE.n61 VSS 0.32806f
C1602 O_SENSE.n62 VSS 2.12976f
C1603 CLKP_HB.n0 VSS 0.1304f
C1604 CLKP_HB.n1 VSS 0.06814f
C1605 CLKP_HB.n2 VSS 0.07304f
C1606 CLKP_HB.n3 VSS 0.06814f
C1607 CLKP_HB.n4 VSS 0.07304f
C1608 CLKP_HB.n5 VSS 0.07304f
C1609 CLKP_HB.n6 VSS 0.07304f
C1610 CLKP_HB.n7 VSS 0.1304f
C1611 CLKP_HB.n8 VSS 0.19488f
C1612 CLKP_HB.n9 VSS 0.1304f
C1613 CLKP_HB.n10 VSS 0.06814f
C1614 CLKP_HB.n11 VSS 0.07304f
C1615 CLKP_HB.n12 VSS 0.06814f
C1616 CLKP_HB.n13 VSS 0.07304f
C1617 CLKP_HB.n14 VSS 0.07304f
C1618 CLKP_HB.n15 VSS 0.07304f
C1619 CLKP_HB.n16 VSS 0.1304f
C1620 CLKP_HB.n17 VSS 0.12705f
C1621 CLKP_HB.n18 VSS 0.93118f
C1622 CLKP_HB.n19 VSS 0.06717f
C1623 CLKP_HB.n20 VSS 0.07304f
C1624 CLKP_HB.n21 VSS 0.07304f
C1625 CLKP_HB.n22 VSS 0.06717f
C1626 CLKP_HB.n23 VSS 0.32062f
C1627 CLKP_HB.n24 VSS 0.06717f
C1628 CLKP_HB.n25 VSS 0.07304f
C1629 CLKP_HB.n26 VSS 0.07304f
C1630 CLKP_HB.n27 VSS 0.06717f
C1631 CLKP_HB.n28 VSS 0.25912f
C1632 CLKP_HB.n29 VSS 0.66183f
C1633 CLKP_HB.n30 VSS 1.19613f
C1634 CLKP_H.n0 VSS 0.05975f
C1635 CLKP_H.n1 VSS 0.06497f
C1636 CLKP_H.n2 VSS 0.06497f
C1637 CLKP_H.n3 VSS 0.05975f
C1638 CLKP_H.n4 VSS 0.28519f
C1639 CLKP_H.n5 VSS 0.05975f
C1640 CLKP_H.n6 VSS 0.06497f
C1641 CLKP_H.n7 VSS 0.06497f
C1642 CLKP_H.n8 VSS 0.05975f
C1643 CLKP_H.n9 VSS 0.23049f
C1644 CLKP_H.n10 VSS 1.74315f
C1645 E_CAPTURE_CLKB.t1 VSS 1.05668f
C1646 E_CAPTURE_CLKB.t14 VSS 0.24602f
C1647 E_CAPTURE_CLKB.t13 VSS 0.24602f
C1648 E_CAPTURE_CLKB.n0 VSS 0.7783f
C1649 E_CAPTURE_CLKB.n1 VSS 0.42781f
C1650 E_CAPTURE_CLKB.t0 VSS 0.24602f
C1651 E_CAPTURE_CLKB.t11 VSS 0.24602f
C1652 E_CAPTURE_CLKB.n2 VSS 0.7783f
C1653 E_CAPTURE_CLKB.n3 VSS 0.22332f
C1654 E_CAPTURE_CLKB.t2 VSS 0.24602f
C1655 E_CAPTURE_CLKB.t6 VSS 0.24602f
C1656 E_CAPTURE_CLKB.n4 VSS 0.7783f
C1657 E_CAPTURE_CLKB.n5 VSS 0.22332f
C1658 E_CAPTURE_CLKB.t3 VSS 1.04969f
C1659 E_CAPTURE_CLKB.n6 VSS 0.46205f
C1660 E_CAPTURE_CLKB.t5 VSS 1.05482f
C1661 E_CAPTURE_CLKB.t8 VSS 0.24602f
C1662 E_CAPTURE_CLKB.t12 VSS 0.24602f
C1663 E_CAPTURE_CLKB.n7 VSS 0.77256f
C1664 E_CAPTURE_CLKB.n8 VSS 0.4354f
C1665 E_CAPTURE_CLKB.t7 VSS 0.24602f
C1666 E_CAPTURE_CLKB.t10 VSS 0.24602f
C1667 E_CAPTURE_CLKB.n9 VSS 0.77256f
C1668 E_CAPTURE_CLKB.n10 VSS 0.22906f
C1669 E_CAPTURE_CLKB.t4 VSS 0.24602f
C1670 E_CAPTURE_CLKB.t9 VSS 0.24602f
C1671 E_CAPTURE_CLKB.n11 VSS 0.77256f
C1672 E_CAPTURE_CLKB.n12 VSS 0.22906f
C1673 E_CAPTURE_CLKB.t15 VSS 1.04782f
C1674 E_CAPTURE_CLKB.n13 VSS 0.3133f
C1675 E_CAPTURE_CLKB.n14 VSS 1.00544f
C1676 E_CAPTURE_CLK.t4 VSS 1.02124f
C1677 E_CAPTURE_CLK.t3 VSS 0.24402f
C1678 E_CAPTURE_CLK.t0 VSS 0.24402f
C1679 E_CAPTURE_CLK.n0 VSS 0.74604f
C1680 E_CAPTURE_CLK.n1 VSS 0.41008f
C1681 E_CAPTURE_CLK.t6 VSS 0.24402f
C1682 E_CAPTURE_CLK.t5 VSS 0.24402f
C1683 E_CAPTURE_CLK.n2 VSS 0.74604f
C1684 E_CAPTURE_CLK.n3 VSS 0.21407f
C1685 E_CAPTURE_CLK.t7 VSS 0.24402f
C1686 E_CAPTURE_CLK.t1 VSS 0.24402f
C1687 E_CAPTURE_CLK.n4 VSS 0.74604f
C1688 E_CAPTURE_CLK.n5 VSS 0.21407f
C1689 E_CAPTURE_CLK.t2 VSS 1.01454f
C1690 E_CAPTURE_CLK.n6 VSS 0.4429f
C1691 E_CAPTURE_CLK.t13 VSS 1.01946f
C1692 E_CAPTURE_CLK.t14 VSS 0.24402f
C1693 E_CAPTURE_CLK.t10 VSS 0.24402f
C1694 E_CAPTURE_CLK.n7 VSS 0.74054f
C1695 E_CAPTURE_CLK.n8 VSS 0.41736f
C1696 E_CAPTURE_CLK.t9 VSS 0.24402f
C1697 E_CAPTURE_CLK.t8 VSS 0.24402f
C1698 E_CAPTURE_CLK.n9 VSS 0.74054f
C1699 E_CAPTURE_CLK.n10 VSS 0.21957f
C1700 E_CAPTURE_CLK.t12 VSS 0.24402f
C1701 E_CAPTURE_CLK.t15 VSS 0.24402f
C1702 E_CAPTURE_CLK.n11 VSS 0.74054f
C1703 E_CAPTURE_CLK.n12 VSS 0.21957f
C1704 E_CAPTURE_CLK.t11 VSS 1.01275f
C1705 E_CAPTURE_CLK.n13 VSS 0.30032f
C1706 E_CAPTURE_CLK.n14 VSS 1.53502f
C1707 E_SENSE.t46 VSS 1.10169f
C1708 E_SENSE.t56 VSS 0.25293f
C1709 E_SENSE.t57 VSS 0.25293f
C1710 E_SENSE.n0 VSS 0.81497f
C1711 E_SENSE.n1 VSS 0.44796f
C1712 E_SENSE.t6 VSS 0.25293f
C1713 E_SENSE.t7 VSS 0.25293f
C1714 E_SENSE.n2 VSS 0.81497f
C1715 E_SENSE.n3 VSS 0.23385f
C1716 E_SENSE.t10 VSS 0.25293f
C1717 E_SENSE.t11 VSS 0.25293f
C1718 E_SENSE.n4 VSS 0.81497f
C1719 E_SENSE.n5 VSS 0.23385f
C1720 E_SENSE.t18 VSS 0.25293f
C1721 E_SENSE.t19 VSS 0.25293f
C1722 E_SENSE.n6 VSS 0.81497f
C1723 E_SENSE.n7 VSS 0.23385f
C1724 E_SENSE.t2 VSS 0.25293f
C1725 E_SENSE.t3 VSS 0.25293f
C1726 E_SENSE.n8 VSS 0.81497f
C1727 E_SENSE.n9 VSS 0.23385f
C1728 E_SENSE.t32 VSS 0.25293f
C1729 E_SENSE.t33 VSS 0.25293f
C1730 E_SENSE.n10 VSS 0.81497f
C1731 E_SENSE.n11 VSS 0.23385f
C1732 E_SENSE.t43 VSS 0.25293f
C1733 E_SENSE.t44 VSS 0.25293f
C1734 E_SENSE.n12 VSS 0.81497f
C1735 E_SENSE.n13 VSS 0.23385f
C1736 E_SENSE.t54 VSS 0.25293f
C1737 E_SENSE.t55 VSS 0.25293f
C1738 E_SENSE.n14 VSS 0.81497f
C1739 E_SENSE.n15 VSS 0.23385f
C1740 E_SENSE.t4 VSS 0.25293f
C1741 E_SENSE.t5 VSS 0.25293f
C1742 E_SENSE.n16 VSS 0.81497f
C1743 E_SENSE.n17 VSS 0.23385f
C1744 E_SENSE.t8 VSS 0.25293f
C1745 E_SENSE.t9 VSS 0.25293f
C1746 E_SENSE.n18 VSS 0.81497f
C1747 E_SENSE.n19 VSS 0.23385f
C1748 E_SENSE.t23 VSS 0.25293f
C1749 E_SENSE.t24 VSS 0.25293f
C1750 E_SENSE.n20 VSS 0.81497f
C1751 E_SENSE.n21 VSS 0.23385f
C1752 E_SENSE.t0 VSS 0.25293f
C1753 E_SENSE.t1 VSS 0.25293f
C1754 E_SENSE.n22 VSS 0.81497f
C1755 E_SENSE.n23 VSS 0.23385f
C1756 E_SENSE.t30 VSS 0.25293f
C1757 E_SENSE.t31 VSS 0.25293f
C1758 E_SENSE.n24 VSS 0.81497f
C1759 E_SENSE.n25 VSS 0.23385f
C1760 E_SENSE.t41 VSS 0.25293f
C1761 E_SENSE.t42 VSS 0.25293f
C1762 E_SENSE.n26 VSS 0.81497f
C1763 E_SENSE.n27 VSS 0.23385f
C1764 E_SENSE.t28 VSS 0.25293f
C1765 E_SENSE.t29 VSS 0.25293f
C1766 E_SENSE.n28 VSS 0.81497f
C1767 E_SENSE.n29 VSS 0.23385f
C1768 E_SENSE.t53 VSS 1.09438f
C1769 E_SENSE.n30 VSS 0.48382f
C1770 E_SENSE.t40 VSS 1.09975f
C1771 E_SENSE.t50 VSS 0.25293f
C1772 E_SENSE.t51 VSS 0.25293f
C1773 E_SENSE.n31 VSS 0.80896f
C1774 E_SENSE.n32 VSS 0.45592f
C1775 E_SENSE.t52 VSS 0.25293f
C1776 E_SENSE.t61 VSS 0.25293f
C1777 E_SENSE.n33 VSS 0.80896f
C1778 E_SENSE.n34 VSS 0.23986f
C1779 E_SENSE.t62 VSS 0.25293f
C1780 E_SENSE.t63 VSS 0.25293f
C1781 E_SENSE.n35 VSS 0.80896f
C1782 E_SENSE.n36 VSS 0.23986f
C1783 E_SENSE.t15 VSS 0.25293f
C1784 E_SENSE.t16 VSS 0.25293f
C1785 E_SENSE.n37 VSS 0.80896f
C1786 E_SENSE.n38 VSS 0.23986f
C1787 E_SENSE.t17 VSS 0.25293f
C1788 E_SENSE.t20 VSS 0.25293f
C1789 E_SENSE.n39 VSS 0.80896f
C1790 E_SENSE.n40 VSS 0.23986f
C1791 E_SENSE.t21 VSS 0.25293f
C1792 E_SENSE.t22 VSS 0.25293f
C1793 E_SENSE.n41 VSS 0.80896f
C1794 E_SENSE.n42 VSS 0.23986f
C1795 E_SENSE.t37 VSS 0.25293f
C1796 E_SENSE.t38 VSS 0.25293f
C1797 E_SENSE.n43 VSS 0.80896f
C1798 E_SENSE.n44 VSS 0.23986f
C1799 E_SENSE.t39 VSS 0.25293f
C1800 E_SENSE.t47 VSS 0.25293f
C1801 E_SENSE.n45 VSS 0.80896f
C1802 E_SENSE.n46 VSS 0.23986f
C1803 E_SENSE.t48 VSS 0.25293f
C1804 E_SENSE.t49 VSS 0.25293f
C1805 E_SENSE.n47 VSS 0.80896f
C1806 E_SENSE.n48 VSS 0.23986f
C1807 E_SENSE.t58 VSS 0.25293f
C1808 E_SENSE.t59 VSS 0.25293f
C1809 E_SENSE.n49 VSS 0.80896f
C1810 E_SENSE.n50 VSS 0.23986f
C1811 E_SENSE.t60 VSS 0.25293f
C1812 E_SENSE.t12 VSS 0.25293f
C1813 E_SENSE.n51 VSS 0.80896f
C1814 E_SENSE.n52 VSS 0.23986f
C1815 E_SENSE.t13 VSS 0.25293f
C1816 E_SENSE.t14 VSS 0.25293f
C1817 E_SENSE.n53 VSS 0.80896f
C1818 E_SENSE.n54 VSS 0.23986f
C1819 E_SENSE.t25 VSS 0.25293f
C1820 E_SENSE.t26 VSS 0.25293f
C1821 E_SENSE.n55 VSS 0.80896f
C1822 E_SENSE.n56 VSS 0.23986f
C1823 E_SENSE.t27 VSS 0.25293f
C1824 E_SENSE.t34 VSS 0.25293f
C1825 E_SENSE.n57 VSS 0.80896f
C1826 E_SENSE.n58 VSS 0.23986f
C1827 E_SENSE.t35 VSS 0.25293f
C1828 E_SENSE.t36 VSS 0.25293f
C1829 E_SENSE.n59 VSS 0.80896f
C1830 E_SENSE.n60 VSS 0.23986f
C1831 E_SENSE.t45 VSS 1.09242f
C1832 E_SENSE.n61 VSS 0.32806f
C1833 E_SENSE.n62 VSS 2.12976f
.ends
