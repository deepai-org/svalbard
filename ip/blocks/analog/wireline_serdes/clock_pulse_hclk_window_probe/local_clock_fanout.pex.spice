* PEX produced using /foss/tools/sak/sak-pex.sh with m=3 and s=1 (extresist threshold=0 mOhm, minres=1 mOhm, mindelay=0 ps)
* NGSPICE file created from local_clock_fanout_pex.ext - technology: gf180mcuD

.subckt local_clock_fanout_pex CLKP_H CLKP_HB CLKN_H CLKN_HB VDD VSS E_SENSE E_CAPTURE_CLK
+ E_CAPTURE_CLKB O_SENSE O_CAPTURE_CLK O_CAPTURE_CLKB
X0 E_CAPTURE_CLKB.t13 a_2700_6400.t12 VSS.t173 VSS.t172 nfet_03v3 ad=2.08p pd=8.52u as=2.08p ps=8.52u w=8u l=0.28u
X1 a_6924_41600.t13 CLKN_H.t2 VSS.t71 VSS.t70 nfet_03v3 ad=2.08p pd=8.52u as=2.08p ps=8.52u w=8u l=0.28u
X2 VDD.t119 a_2700_6400.t21 E_CAPTURE_CLKB.t8 VDD.t118 pfet_03v3 ad=2.08p pd=8.52u as=2.08p ps=8.52u w=8u l=0.28u
X3 VDD.t19 a_2700_41600.t23 O_CAPTURE_CLKB.t3 VDD.t18 pfet_03v3 ad=2.08p pd=8.52u as=3.52p ps=16.88u w=8u l=0.28u
X4 VSS.t81 a_6924_6400.t27 E_SENSE.t20 VSS.t80 nfet_03v3 ad=2.08p pd=8.52u as=2.08p ps=8.52u w=8u l=0.28u
X5 O_CAPTURE_CLKB.t12 a_2700_41600.t14 VSS.t159 VSS.t158 nfet_03v3 ad=2.08p pd=8.52u as=2.08p ps=8.52u w=8u l=0.28u
X6 VSS.t19 a_6924_6400.t25 E_SENSE.t7 VSS.t18 nfet_03v3 ad=2.08p pd=8.52u as=2.08p ps=8.52u w=8u l=0.28u
X7 VSS.t149 CLKP_H.t5 a_6924_6400.t10 VSS.t148 nfet_03v3 ad=2.08p pd=8.52u as=2.08p ps=8.52u w=8u l=0.28u
X8 E_SENSE.t10 a_6924_6400.t44 VDD.t27 VDD.t26 pfet_03v3 ad=2.08p pd=8.52u as=2.08p ps=8.52u w=8u l=0.28u
X9 E_SENSE.t17 a_6924_6400.t42 VDD.t91 VDD.t90 pfet_03v3 ad=2.08p pd=8.52u as=2.08p ps=8.52u w=8u l=0.28u
X10 a_6924_6400.t1 CLKP_H.t18 VDD.t149 VDD.t148 pfet_03v3 ad=2.08p pd=8.52u as=2.08p ps=8.52u w=8u l=0.28u
X11 E_CAPTURE_CLKB.t15 a_2700_6400.t16 VDD.t183 VDD.t182 pfet_03v3 ad=3.52p pd=16.88u as=2.08p ps=8.52u w=8u l=0.28u
X12 VDD.t163 CLKP_H.t19 a_6924_6400.t0 VDD.t162 pfet_03v3 ad=2.08p pd=8.52u as=3.52p ps=16.88u w=8u l=0.28u
X13 E_SENSE.t12 a_6924_6400.t18 VSS.t33 VSS.t32 nfet_03v3 ad=2.08p pd=8.52u as=2.08p ps=8.52u w=8u l=0.28u
X14 VDD.t105 a_6924_6400.t37 E_SENSE.t18 VDD.t104 pfet_03v3 ad=2.08p pd=8.52u as=2.08p ps=8.52u w=8u l=0.28u
X15 VDD.t171 CLKP_H.t13 a_6924_6400.t6 VDD.t170 pfet_03v3 ad=2.08p pd=8.52u as=2.08p ps=8.52u w=8u l=0.28u
X16 O_CAPTURE_CLK.t8 a_4812_41600.t18 VDD.t21 VDD.t20 pfet_03v3 ad=2.08p pd=8.52u as=2.08p ps=8.52u w=8u l=0.28u
X17 VDD.t49 a_2700_6400.t17 E_CAPTURE_CLKB.t3 VDD.t48 pfet_03v3 ad=2.08p pd=8.52u as=2.08p ps=8.52u w=8u l=0.28u
X18 E_CAPTURE_CLK.t10 a_4812_6400.t12 VSS.t85 VSS.t84 nfet_03v3 ad=2.08p pd=8.52u as=2.08p ps=8.52u w=8u l=0.28u
X19 VDD.t115 a_6924_6400.t35 E_SENSE.t22 VDD.t114 pfet_03v3 ad=2.08p pd=8.52u as=2.08p ps=8.52u w=8u l=0.28u
X20 O_SENSE.t26 a_6924_41600.t46 VDD.t187 VDD.t186 pfet_03v3 ad=2.08p pd=8.52u as=2.08p ps=8.52u w=8u l=0.28u
X21 VSS.t175 a_6924_41600.t19 O_SENSE.t21 VSS.t174 nfet_03v3 ad=2.08p pd=8.52u as=2.08p ps=8.52u w=8u l=0.28u
X22 O_CAPTURE_CLKB.t6 a_2700_41600.t20 VDD.t55 VDD.t54 pfet_03v3 ad=2.08p pd=8.52u as=2.08p ps=8.52u w=8u l=0.28u
X23 E_SENSE.t19 a_6924_6400.t38 VDD.t107 VDD.t106 pfet_03v3 ad=2.08p pd=8.52u as=2.08p ps=8.52u w=8u l=0.28u
X24 a_6924_6400.t5 CLKP_H.t14 VDD.t169 VDD.t168 pfet_03v3 ad=2.08p pd=8.52u as=2.08p ps=8.52u w=8u l=0.28u
X25 a_6924_41600.t15 CLKN_H.t0 VSS.t75 VSS.t74 nfet_03v3 ad=3.52p pd=16.88u as=2.08p ps=8.52u w=8u l=0.28u
X26 VSS.t9 a_2700_41600.t11 O_CAPTURE_CLKB.t0 VSS.t8 nfet_03v3 ad=2.08p pd=8.52u as=2.08p ps=8.52u w=8u l=0.28u
X27 VSS.t87 a_4812_6400.t13 E_CAPTURE_CLK.t11 VSS.t86 nfet_03v3 ad=2.08p pd=8.52u as=2.08p ps=8.52u w=8u l=0.28u
X28 E_SENSE.t23 a_6924_6400.t36 VDD.t117 VDD.t116 pfet_03v3 ad=2.08p pd=8.52u as=2.08p ps=8.52u w=8u l=0.28u
X29 a_6924_6400.t7 CLKP_H.t12 VDD.t151 VDD.t150 pfet_03v3 ad=3.52p pd=16.88u as=2.08p ps=8.52u w=8u l=0.28u
X30 VDD.t127 a_6924_41600.t43 O_SENSE.t6 VDD.t126 pfet_03v3 ad=2.08p pd=8.52u as=2.08p ps=8.52u w=8u l=0.28u
X31 O_SENSE.t31 a_6924_41600.t16 VSS.t191 VSS.t190 nfet_03v3 ad=3.52p pd=16.88u as=2.08p ps=8.52u w=8u l=0.28u
X32 VSS.t103 a_4812_6400.t11 E_CAPTURE_CLK.t13 VSS.t102 nfet_03v3 ad=2.08p pd=8.52u as=2.08p ps=8.52u w=8u l=0.28u
X33 E_CAPTURE_CLK.t0 a_4812_6400.t22 VDD.t7 VDD.t6 pfet_03v3 ad=2.08p pd=8.52u as=2.08p ps=8.52u w=8u l=0.28u
X34 VDD.t81 a_2700_41600.t17 O_CAPTURE_CLKB.t7 VDD.t80 pfet_03v3 ad=2.08p pd=8.52u as=2.08p ps=8.52u w=8u l=0.28u
X35 a_4812_41600.t5 CLKN_H.t10 VSS.t57 VSS.t56 nfet_03v3 ad=2.08p pd=8.52u as=2.08p ps=8.52u w=8u l=0.28u
X36 VSS.t49 a_4812_41600.t15 O_CAPTURE_CLK.t11 VSS.t48 nfet_03v3 ad=2.08p pd=8.52u as=3.52p ps=16.88u w=8u l=0.28u
X37 a_4812_41600.t3 CLKN_H.t20 VDD.t65 VDD.t64 pfet_03v3 ad=3.52p pd=16.88u as=2.08p ps=8.52u w=8u l=0.28u
X38 E_CAPTURE_CLKB.t11 a_2700_6400.t14 VSS.t111 VSS.t110 nfet_03v3 ad=2.08p pd=8.52u as=2.08p ps=8.52u w=8u l=0.28u
X39 VDD.t99 a_4812_41600.t21 O_CAPTURE_CLK.t15 VDD.t98 pfet_03v3 ad=2.08p pd=8.52u as=2.08p ps=8.52u w=8u l=0.28u
X40 VSS.t41 CLKN_HB.t1 a_2700_41600.t6 VSS.t40 nfet_03v3 ad=2.08p pd=8.52u as=2.08p ps=8.52u w=8u l=0.28u
X41 a_6924_41600.t9 CLKN_H.t6 VSS.t53 VSS.t52 nfet_03v3 ad=2.08p pd=8.52u as=2.08p ps=8.52u w=8u l=0.28u
X42 VDD.t109 a_2700_6400.t23 E_CAPTURE_CLKB.t5 VDD.t108 pfet_03v3 ad=2.08p pd=8.52u as=3.52p ps=16.88u w=8u l=0.28u
X43 a_2700_6400.t5 CLKP_HB.t2 VSS.t129 VSS.t128 nfet_03v3 ad=2.08p pd=8.52u as=2.08p ps=8.52u w=8u l=0.28u
X44 VDD.t9 a_4812_6400.t23 E_CAPTURE_CLK.t1 VDD.t8 pfet_03v3 ad=2.08p pd=8.52u as=3.52p ps=16.88u w=8u l=0.28u
X45 a_6924_41600.t3 CLKN_H.t16 VDD.t71 VDD.t70 pfet_03v3 ad=2.08p pd=8.52u as=2.08p ps=8.52u w=8u l=0.28u
X46 a_2700_6400.t7 CLKP_HB.t0 VSS.t125 VSS.t124 nfet_03v3 ad=3.52p pd=16.88u as=2.08p ps=8.52u w=8u l=0.28u
X47 VDD.t141 CLKP_HB.t7 a_2700_6400.t0 VDD.t140 pfet_03v3 ad=2.08p pd=8.52u as=3.52p ps=16.88u w=8u l=0.28u
X48 VSS.t69 CLKN_H.t3 a_6924_41600.t12 VSS.t68 nfet_03v3 ad=2.08p pd=8.52u as=2.08p ps=8.52u w=8u l=0.28u
X49 a_4812_6400.t7 CLKP_H.t8 VSS.t145 VSS.t144 nfet_03v3 ad=3.52p pd=16.88u as=2.08p ps=8.52u w=8u l=0.28u
X50 VDD.t79 CLKN_H.t13 a_6924_41600.t6 VDD.t78 pfet_03v3 ad=2.08p pd=8.52u as=2.08p ps=8.52u w=8u l=0.28u
X51 VSS.t179 a_2700_41600.t15 O_CAPTURE_CLKB.t14 VSS.t178 nfet_03v3 ad=2.08p pd=8.52u as=3.52p ps=16.88u w=8u l=0.28u
X52 VSS.t131 CLKP_HB.t1 a_2700_6400.t6 VSS.t130 nfet_03v3 ad=2.08p pd=8.52u as=2.08p ps=8.52u w=8u l=0.28u
X53 VSS.t133 CLKP_H.t11 a_4812_6400.t4 VSS.t132 nfet_03v3 ad=2.08p pd=8.52u as=3.52p ps=16.88u w=8u l=0.28u
X54 VSS.t139 CLKP_H.t9 a_4812_6400.t6 VSS.t138 nfet_03v3 ad=2.08p pd=8.52u as=2.08p ps=8.52u w=8u l=0.28u
X55 E_CAPTURE_CLK.t8 a_4812_6400.t16 VDD.t93 VDD.t92 pfet_03v3 ad=3.52p pd=16.88u as=2.08p ps=8.52u w=8u l=0.28u
X56 a_4812_6400.t1 CLKP_H.t22 VDD.t159 VDD.t158 pfet_03v3 ad=2.08p pd=8.52u as=2.08p ps=8.52u w=8u l=0.28u
X57 a_2700_41600.t1 CLKN_HB.t6 VDD.t37 VDD.t36 pfet_03v3 ad=2.08p pd=8.52u as=2.08p ps=8.52u w=8u l=0.28u
X58 VDD.t131 a_6924_41600.t41 O_SENSE.t10 VDD.t130 pfet_03v3 ad=2.08p pd=8.52u as=2.08p ps=8.52u w=8u l=0.28u
X59 VSS.t109 a_2700_6400.t13 E_CAPTURE_CLKB.t10 VSS.t108 nfet_03v3 ad=2.08p pd=8.52u as=2.08p ps=8.52u w=8u l=0.28u
X60 E_SENSE.t21 a_6924_6400.t28 VSS.t83 VSS.t82 nfet_03v3 ad=2.08p pd=8.52u as=2.08p ps=8.52u w=8u l=0.28u
X61 VDD.t23 a_4812_41600.t19 O_CAPTURE_CLK.t9 VDD.t22 pfet_03v3 ad=2.08p pd=8.52u as=2.08p ps=8.52u w=8u l=0.28u
X62 O_SENSE.t20 a_6924_41600.t38 VDD.t179 VDD.t178 pfet_03v3 ad=2.08p pd=8.52u as=2.08p ps=8.52u w=8u l=0.28u
X63 E_SENSE.t8 a_6924_6400.t26 VSS.t21 VSS.t20 nfet_03v3 ad=2.08p pd=8.52u as=2.08p ps=8.52u w=8u l=0.28u
X64 a_6924_6400.t9 CLKP_H.t6 VSS.t135 VSS.t134 nfet_03v3 ad=2.08p pd=8.52u as=2.08p ps=8.52u w=8u l=0.28u
X65 VDD.t3 a_6924_6400.t45 E_SENSE.t3 VDD.t2 pfet_03v3 ad=2.08p pd=8.52u as=2.08p ps=8.52u w=8u l=0.28u
X66 O_CAPTURE_CLK.t0 a_4812_41600.t10 VSS.t5 VSS.t4 nfet_03v3 ad=2.08p pd=8.52u as=2.08p ps=8.52u w=8u l=0.28u
X67 VDD.t135 a_6924_41600.t47 O_SENSE.t14 VDD.t134 pfet_03v3 ad=2.08p pd=8.52u as=3.52p ps=16.88u w=8u l=0.28u
X68 VDD.t101 a_2700_41600.t21 O_CAPTURE_CLKB.t9 VDD.t100 pfet_03v3 ad=2.08p pd=8.52u as=2.08p ps=8.52u w=8u l=0.28u
X69 O_CAPTURE_CLK.t4 a_4812_41600.t16 VDD.t15 VDD.t14 pfet_03v3 ad=3.52p pd=16.88u as=2.08p ps=8.52u w=8u l=0.28u
X70 E_CAPTURE_CLKB.t0 a_2700_6400.t8 VSS.t23 VSS.t22 nfet_03v3 ad=3.52p pd=16.88u as=2.08p ps=8.52u w=8u l=0.28u
X71 O_SENSE.t28 a_6924_41600.t30 VSS.t189 VSS.t188 nfet_03v3 ad=2.08p pd=8.52u as=2.08p ps=8.52u w=8u l=0.28u
X72 O_CAPTURE_CLKB.t1 a_2700_41600.t12 VSS.t11 VSS.t10 nfet_03v3 ad=2.08p pd=8.52u as=2.08p ps=8.52u w=8u l=0.28u
X73 VSS.t147 CLKP_H.t7 a_6924_6400.t8 VSS.t146 nfet_03v3 ad=2.08p pd=8.52u as=3.52p ps=16.88u w=8u l=0.28u
X74 E_SENSE.t4 a_6924_6400.t46 VDD.t5 VDD.t4 pfet_03v3 ad=2.08p pd=8.52u as=2.08p ps=8.52u w=8u l=0.28u
X75 O_SENSE.t7 a_6924_41600.t44 VDD.t129 VDD.t128 pfet_03v3 ad=2.08p pd=8.52u as=2.08p ps=8.52u w=8u l=0.28u
X76 O_CAPTURE_CLKB.t8 a_2700_41600.t18 VDD.t83 VDD.t82 pfet_03v3 ad=2.08p pd=8.52u as=2.08p ps=8.52u w=8u l=0.28u
X77 VSS.t97 a_6924_6400.t21 E_SENSE.t24 VSS.t96 nfet_03v3 ad=2.08p pd=8.52u as=2.08p ps=8.52u w=8u l=0.28u
X78 VSS.t155 CLKP_H.t1 a_6924_6400.t14 VSS.t154 nfet_03v3 ad=2.08p pd=8.52u as=2.08p ps=8.52u w=8u l=0.28u
X79 VSS.t117 a_6924_41600.t27 O_SENSE.t12 VSS.t116 nfet_03v3 ad=2.08p pd=8.52u as=2.08p ps=8.52u w=8u l=0.28u
X80 VSS.t15 a_6924_6400.t19 E_SENSE.t5 VSS.t14 nfet_03v3 ad=2.08p pd=8.52u as=2.08p ps=8.52u w=8u l=0.28u
X81 VSS.t89 a_2700_6400.t9 E_CAPTURE_CLKB.t6 VSS.t88 nfet_03v3 ad=2.08p pd=8.52u as=2.08p ps=8.52u w=8u l=0.28u
X82 O_CAPTURE_CLK.t2 a_4812_41600.t22 VDD.t11 VDD.t10 pfet_03v3 ad=2.08p pd=8.52u as=2.08p ps=8.52u w=8u l=0.28u
X83 VSS.t13 a_2700_41600.t9 O_CAPTURE_CLKB.t2 VSS.t12 nfet_03v3 ad=2.08p pd=8.52u as=2.08p ps=8.52u w=8u l=0.28u
X84 E_CAPTURE_CLKB.t4 a_2700_6400.t18 VDD.t51 VDD.t50 pfet_03v3 ad=2.08p pd=8.52u as=2.08p ps=8.52u w=8u l=0.28u
X85 a_2700_41600.t3 CLKN_HB.t4 VDD.t33 VDD.t32 pfet_03v3 ad=3.52p pd=16.88u as=2.08p ps=8.52u w=8u l=0.28u
X86 a_4812_41600.t7 CLKN_H.t8 VSS.t61 VSS.t60 nfet_03v3 ad=3.52p pd=16.88u as=2.08p ps=8.52u w=8u l=0.28u
X87 VSS.t27 a_4812_41600.t13 O_CAPTURE_CLK.t7 VSS.t26 nfet_03v3 ad=2.08p pd=8.52u as=2.08p ps=8.52u w=8u l=0.28u
X88 E_SENSE.t25 a_6924_6400.t22 VSS.t99 VSS.t98 nfet_03v3 ad=2.08p pd=8.52u as=2.08p ps=8.52u w=8u l=0.28u
X89 a_6924_6400.t13 CLKP_H.t2 VSS.t153 VSS.t152 nfet_03v3 ad=2.08p pd=8.52u as=2.08p ps=8.52u w=8u l=0.28u
X90 E_SENSE.t6 a_6924_6400.t20 VSS.t17 VSS.t16 nfet_03v3 ad=2.08p pd=8.52u as=2.08p ps=8.52u w=8u l=0.28u
X91 a_6924_6400.t15 CLKP_H.t0 VSS.t141 VSS.t140 nfet_03v3 ad=3.52p pd=16.88u as=2.08p ps=8.52u w=8u l=0.28u
X92 VDD.t173 a_6924_6400.t39 E_SENSE.t28 VDD.t172 pfet_03v3 ad=2.08p pd=8.52u as=2.08p ps=8.52u w=8u l=0.28u
X93 VDD.t157 CLKP_H.t15 a_6924_6400.t4 VDD.t156 pfet_03v3 ad=2.08p pd=8.52u as=2.08p ps=8.52u w=8u l=0.28u
X94 a_6924_41600.t11 CLKN_H.t4 VSS.t67 VSS.t66 nfet_03v3 ad=2.08p pd=8.52u as=2.08p ps=8.52u w=8u l=0.28u
X95 VDD.t41 a_2700_6400.t19 E_CAPTURE_CLKB.t1 VDD.t40 pfet_03v3 ad=2.08p pd=8.52u as=2.08p ps=8.52u w=8u l=0.28u
X96 E_CAPTURE_CLK.t14 a_4812_6400.t14 VSS.t167 VSS.t166 nfet_03v3 ad=2.08p pd=8.52u as=2.08p ps=8.52u w=8u l=0.28u
X97 O_SENSE.t1 a_6924_41600.t36 VDD.t113 VDD.t112 pfet_03v3 ad=2.08p pd=8.52u as=2.08p ps=8.52u w=8u l=0.28u
X98 VSS.t73 CLKN_H.t1 a_6924_41600.t14 VSS.t72 nfet_03v3 ad=2.08p pd=8.52u as=2.08p ps=8.52u w=8u l=0.28u
X99 VSS.t181 a_2700_6400.t15 E_CAPTURE_CLKB.t14 VSS.t180 nfet_03v3 ad=2.08p pd=8.52u as=3.52p ps=16.88u w=8u l=0.28u
X100 VDD.t189 a_6924_41600.t33 O_SENSE.t29 VDD.t188 pfet_03v3 ad=2.08p pd=8.52u as=2.08p ps=8.52u w=8u l=0.28u
X101 VSS.t169 a_4812_6400.t15 E_CAPTURE_CLK.t15 VSS.t168 nfet_03v3 ad=2.08p pd=8.52u as=3.52p ps=16.88u w=8u l=0.28u
X102 VSS.t127 CLKP_HB.t3 a_2700_6400.t4 VSS.t126 nfet_03v3 ad=2.08p pd=8.52u as=3.52p ps=16.88u w=8u l=0.28u
X103 VDD.t35 CLKN_HB.t7 a_2700_41600.t0 VDD.t34 pfet_03v3 ad=2.08p pd=8.52u as=3.52p ps=16.88u w=8u l=0.28u
X104 O_SENSE.t11 a_6924_41600.t42 VDD.t133 VDD.t132 pfet_03v3 ad=2.08p pd=8.52u as=2.08p ps=8.52u w=8u l=0.28u
X105 E_SENSE.t27 a_6924_6400.t32 VDD.t125 VDD.t124 pfet_03v3 ad=3.52p pd=16.88u as=2.08p ps=8.52u w=8u l=0.28u
X106 VDD.t67 CLKN_H.t19 a_6924_41600.t0 VDD.t66 pfet_03v3 ad=2.08p pd=8.52u as=3.52p ps=16.88u w=8u l=0.28u
X107 a_2700_41600.t5 CLKN_HB.t2 VSS.t39 VSS.t38 nfet_03v3 ad=2.08p pd=8.52u as=2.08p ps=8.52u w=8u l=0.28u
X108 VSS.t121 a_6924_41600.t25 O_SENSE.t17 VSS.t120 nfet_03v3 ad=2.08p pd=8.52u as=2.08p ps=8.52u w=8u l=0.28u
X109 VDD.t137 a_6924_41600.t39 O_SENSE.t15 VDD.t136 pfet_03v3 ad=2.08p pd=8.52u as=2.08p ps=8.52u w=8u l=0.28u
X110 VDD.t45 a_6924_6400.t33 E_SENSE.t13 VDD.t44 pfet_03v3 ad=2.08p pd=8.52u as=2.08p ps=8.52u w=8u l=0.28u
X111 VSS.t7 a_4812_41600.t11 O_CAPTURE_CLK.t1 VSS.t6 nfet_03v3 ad=2.08p pd=8.52u as=2.08p ps=8.52u w=8u l=0.28u
X112 E_CAPTURE_CLK.t4 a_4812_6400.t8 VSS.t43 VSS.t42 nfet_03v3 ad=3.52p pd=16.88u as=2.08p ps=8.52u w=8u l=0.28u
X113 O_SENSE.t9 a_6924_41600.t22 VSS.t115 VSS.t114 nfet_03v3 ad=2.08p pd=8.52u as=2.08p ps=8.52u w=8u l=0.28u
X114 VDD.t17 a_4812_41600.t17 O_CAPTURE_CLK.t5 VDD.t16 pfet_03v3 ad=2.08p pd=8.52u as=2.08p ps=8.52u w=8u l=0.28u
X115 a_4812_6400.t5 CLKP_H.t10 VSS.t137 VSS.t136 nfet_03v3 ad=2.08p pd=8.52u as=2.08p ps=8.52u w=8u l=0.28u
X116 VDD.t95 a_4812_6400.t17 E_CAPTURE_CLK.t9 VDD.t94 pfet_03v3 ad=2.08p pd=8.52u as=2.08p ps=8.52u w=8u l=0.28u
X117 VSS.t105 a_6924_41600.t31 O_SENSE.t4 VSS.t104 nfet_03v3 ad=2.08p pd=8.52u as=3.52p ps=16.88u w=8u l=0.28u
X118 VSS.t157 a_2700_41600.t13 O_CAPTURE_CLKB.t11 VSS.t156 nfet_03v3 ad=2.08p pd=8.52u as=2.08p ps=8.52u w=8u l=0.28u
X119 O_CAPTURE_CLK.t12 a_4812_41600.t8 VSS.t77 VSS.t76 nfet_03v3 ad=3.52p pd=16.88u as=2.08p ps=8.52u w=8u l=0.28u
X120 VDD.t185 a_6924_41600.t45 O_SENSE.t25 VDD.t184 pfet_03v3 ad=2.08p pd=8.52u as=2.08p ps=8.52u w=8u l=0.28u
X121 O_SENSE.t13 a_6924_41600.t28 VSS.t119 VSS.t118 nfet_03v3 ad=2.08p pd=8.52u as=2.08p ps=8.52u w=8u l=0.28u
X122 VSS.t163 a_6924_6400.t29 E_SENSE.t30 VSS.t162 nfet_03v3 ad=2.08p pd=8.52u as=2.08p ps=8.52u w=8u l=0.28u
X123 E_CAPTURE_CLK.t6 a_4812_6400.t18 VDD.t85 VDD.t84 pfet_03v3 ad=2.08p pd=8.52u as=2.08p ps=8.52u w=8u l=0.28u
X124 VDD.t61 CLKN_H.t23 a_4812_41600.t0 VDD.t60 pfet_03v3 ad=2.08p pd=8.52u as=3.52p ps=16.88u w=8u l=0.28u
X125 O_CAPTURE_CLKB.t4 a_2700_41600.t10 VSS.t29 VSS.t28 nfet_03v3 ad=2.08p pd=8.52u as=2.08p ps=8.52u w=8u l=0.28u
X126 O_CAPTURE_CLKB.t15 a_2700_41600.t16 VDD.t181 VDD.t180 pfet_03v3 ad=3.52p pd=16.88u as=2.08p ps=8.52u w=8u l=0.28u
X127 O_CAPTURE_CLK.t10 a_4812_41600.t14 VSS.t47 VSS.t46 nfet_03v3 ad=2.08p pd=8.52u as=2.08p ps=8.52u w=8u l=0.28u
X128 O_CAPTURE_CLK.t14 a_4812_41600.t20 VDD.t97 VDD.t96 pfet_03v3 ad=2.08p pd=8.52u as=2.08p ps=8.52u w=8u l=0.28u
X129 a_2700_41600.t7 CLKN_HB.t0 VSS.t35 VSS.t34 nfet_03v3 ad=3.52p pd=16.88u as=2.08p ps=8.52u w=8u l=0.28u
X130 E_SENSE.t31 a_6924_6400.t30 VSS.t165 VSS.t164 nfet_03v3 ad=2.08p pd=8.52u as=2.08p ps=8.52u w=8u l=0.28u
X131 VDD.t1 a_6924_6400.t47 E_SENSE.t0 VDD.t0 pfet_03v3 ad=2.08p pd=8.52u as=3.52p ps=16.88u w=8u l=0.28u
X132 O_SENSE.t22 a_6924_41600.t20 VSS.t177 VSS.t176 nfet_03v3 ad=2.08p pd=8.52u as=2.08p ps=8.52u w=8u l=0.28u
X133 E_CAPTURE_CLKB.t7 a_2700_6400.t10 VSS.t91 VSS.t90 nfet_03v3 ad=2.08p pd=8.52u as=2.08p ps=8.52u w=8u l=0.28u
X134 O_SENSE.t30 a_6924_41600.t34 VDD.t191 VDD.t190 pfet_03v3 ad=2.08p pd=8.52u as=2.08p ps=8.52u w=8u l=0.28u
X135 VSS.t93 a_6924_41600.t17 O_SENSE.t2 VSS.t92 nfet_03v3 ad=2.08p pd=8.52u as=2.08p ps=8.52u w=8u l=0.28u
X136 VSS.t1 a_6924_6400.t23 E_SENSE.t1 VSS.t0 nfet_03v3 ad=2.08p pd=8.52u as=2.08p ps=8.52u w=8u l=0.28u
X137 VSS.t143 CLKP_H.t3 a_6924_6400.t12 VSS.t142 nfet_03v3 ad=2.08p pd=8.52u as=2.08p ps=8.52u w=8u l=0.28u
X138 VSS.t171 a_2700_6400.t11 E_CAPTURE_CLKB.t12 VSS.t170 nfet_03v3 ad=2.08p pd=8.52u as=2.08p ps=8.52u w=8u l=0.28u
X139 E_SENSE.t29 a_6924_6400.t40 VDD.t175 VDD.t174 pfet_03v3 ad=2.08p pd=8.52u as=2.08p ps=8.52u w=8u l=0.28u
X140 a_6924_6400.t3 CLKP_H.t16 VDD.t167 VDD.t166 pfet_03v3 ad=2.08p pd=8.52u as=2.08p ps=8.52u w=8u l=0.28u
X141 VSS.t37 CLKN_HB.t3 a_2700_41600.t4 VSS.t36 nfet_03v3 ad=2.08p pd=8.52u as=3.52p ps=16.88u w=8u l=0.28u
X142 O_SENSE.t18 a_6924_41600.t26 VSS.t123 VSS.t122 nfet_03v3 ad=2.08p pd=8.52u as=2.08p ps=8.52u w=8u l=0.28u
X143 E_CAPTURE_CLKB.t2 a_2700_6400.t20 VDD.t43 VDD.t42 pfet_03v3 ad=2.08p pd=8.52u as=2.08p ps=8.52u w=8u l=0.28u
X144 VDD.t59 CLKN_H.t21 a_4812_41600.t2 VDD.t58 pfet_03v3 ad=2.08p pd=8.52u as=2.08p ps=8.52u w=8u l=0.28u
X145 O_SENSE.t16 a_6924_41600.t40 VDD.t139 VDD.t138 pfet_03v3 ad=2.08p pd=8.52u as=2.08p ps=8.52u w=8u l=0.28u
X146 VSS.t63 CLKN_H.t7 a_6924_41600.t8 VSS.t62 nfet_03v3 ad=2.08p pd=8.52u as=3.52p ps=16.88u w=8u l=0.28u
X147 VDD.t25 a_6924_6400.t43 E_SENSE.t9 VDD.t24 pfet_03v3 ad=2.08p pd=8.52u as=2.08p ps=8.52u w=8u l=0.28u
X148 VDD.t69 CLKN_H.t17 a_6924_41600.t2 VDD.t68 pfet_03v3 ad=2.08p pd=8.52u as=2.08p ps=8.52u w=8u l=0.28u
X149 VSS.t183 a_6924_41600.t23 O_SENSE.t23 VSS.t182 nfet_03v3 ad=2.08p pd=8.52u as=2.08p ps=8.52u w=8u l=0.28u
X150 VDD.t89 a_6924_6400.t41 E_SENSE.t16 VDD.t88 pfet_03v3 ad=2.08p pd=8.52u as=2.08p ps=8.52u w=8u l=0.28u
X151 VDD.t165 CLKP_H.t17 a_6924_6400.t2 VDD.t164 pfet_03v3 ad=2.08p pd=8.52u as=2.08p ps=8.52u w=8u l=0.28u
X152 VDD.t177 a_6924_41600.t37 O_SENSE.t19 VDD.t176 pfet_03v3 ad=2.08p pd=8.52u as=2.08p ps=8.52u w=8u l=0.28u
X153 E_SENSE.t15 a_6924_6400.t16 VSS.t51 VSS.t50 nfet_03v3 ad=3.52p pd=16.88u as=2.08p ps=8.52u w=8u l=0.28u
X154 a_6924_41600.t5 CLKN_H.t14 VDD.t77 VDD.t76 pfet_03v3 ad=2.08p pd=8.52u as=2.08p ps=8.52u w=8u l=0.28u
X155 VSS.t79 a_4812_41600.t9 O_CAPTURE_CLK.t13 VSS.t78 nfet_03v3 ad=2.08p pd=8.52u as=2.08p ps=8.52u w=8u l=0.28u
X156 O_CAPTURE_CLKB.t10 a_2700_41600.t22 VDD.t103 VDD.t102 pfet_03v3 ad=2.08p pd=8.52u as=2.08p ps=8.52u w=8u l=0.28u
X157 VSS.t187 a_6924_41600.t29 O_SENSE.t27 VSS.t186 nfet_03v3 ad=2.08p pd=8.52u as=2.08p ps=8.52u w=8u l=0.28u
X158 VSS.t31 a_6924_6400.t17 E_SENSE.t11 VSS.t30 nfet_03v3 ad=2.08p pd=8.52u as=2.08p ps=8.52u w=8u l=0.28u
X159 E_SENSE.t14 a_6924_6400.t34 VDD.t47 VDD.t46 pfet_03v3 ad=2.08p pd=8.52u as=2.08p ps=8.52u w=8u l=0.28u
X160 VSS.t55 CLKN_H.t11 a_4812_41600.t4 VSS.t54 nfet_03v3 ad=2.08p pd=8.52u as=3.52p ps=16.88u w=8u l=0.28u
X161 VSS.t45 a_4812_6400.t9 E_CAPTURE_CLK.t5 VSS.t44 nfet_03v3 ad=2.08p pd=8.52u as=2.08p ps=8.52u w=8u l=0.28u
X162 E_CAPTURE_CLK.t2 a_4812_6400.t20 VDD.t29 VDD.t28 pfet_03v3 ad=2.08p pd=8.52u as=2.08p ps=8.52u w=8u l=0.28u
X163 O_CAPTURE_CLKB.t13 a_2700_41600.t8 VSS.t161 VSS.t160 nfet_03v3 ad=3.52p pd=16.88u as=2.08p ps=8.52u w=8u l=0.28u
X164 O_CAPTURE_CLK.t6 a_4812_41600.t12 VSS.t25 VSS.t24 nfet_03v3 ad=2.08p pd=8.52u as=2.08p ps=8.52u w=8u l=0.28u
X165 E_CAPTURE_CLK.t12 a_4812_6400.t10 VSS.t101 VSS.t100 nfet_03v3 ad=2.08p pd=8.52u as=2.08p ps=8.52u w=8u l=0.28u
X166 VDD.t31 a_4812_6400.t21 E_CAPTURE_CLK.t3 VDD.t30 pfet_03v3 ad=2.08p pd=8.52u as=2.08p ps=8.52u w=8u l=0.28u
X167 VDD.t87 a_4812_6400.t19 E_CAPTURE_CLK.t7 VDD.t86 pfet_03v3 ad=2.08p pd=8.52u as=2.08p ps=8.52u w=8u l=0.28u
X168 VDD.t111 a_6924_41600.t35 O_SENSE.t0 VDD.t110 pfet_03v3 ad=2.08p pd=8.52u as=2.08p ps=8.52u w=8u l=0.28u
X169 E_CAPTURE_CLKB.t9 a_2700_6400.t22 VDD.t121 VDD.t120 pfet_03v3 ad=2.08p pd=8.52u as=2.08p ps=8.52u w=8u l=0.28u
X170 a_6924_41600.t7 CLKN_H.t12 VDD.t73 VDD.t72 pfet_03v3 ad=3.52p pd=16.88u as=2.08p ps=8.52u w=8u l=0.28u
X171 O_SENSE.t3 a_6924_41600.t18 VSS.t95 VSS.t94 nfet_03v3 ad=2.08p pd=8.52u as=2.08p ps=8.52u w=8u l=0.28u
X172 a_2700_6400.t1 CLKP_HB.t6 VDD.t143 VDD.t142 pfet_03v3 ad=2.08p pd=8.52u as=2.08p ps=8.52u w=8u l=0.28u
X173 VDD.t53 a_2700_41600.t19 O_CAPTURE_CLKB.t5 VDD.t52 pfet_03v3 ad=2.08p pd=8.52u as=2.08p ps=8.52u w=8u l=0.28u
X174 VSS.t107 a_6924_6400.t31 E_SENSE.t26 VSS.t106 nfet_03v3 ad=2.08p pd=8.52u as=3.52p ps=16.88u w=8u l=0.28u
X175 a_2700_6400.t3 CLKP_HB.t4 VDD.t147 VDD.t146 pfet_03v3 ad=3.52p pd=16.88u as=2.08p ps=8.52u w=8u l=0.28u
X176 O_SENSE.t5 a_6924_41600.t32 VDD.t123 VDD.t122 pfet_03v3 ad=3.52p pd=16.88u as=2.08p ps=8.52u w=8u l=0.28u
X177 a_4812_41600.t1 CLKN_H.t22 VDD.t63 VDD.t62 pfet_03v3 ad=2.08p pd=8.52u as=2.08p ps=8.52u w=8u l=0.28u
X178 VDD.t13 a_4812_41600.t23 O_CAPTURE_CLK.t3 VDD.t12 pfet_03v3 ad=2.08p pd=8.52u as=3.52p ps=16.88u w=8u l=0.28u
X179 a_4812_6400.t3 CLKP_H.t20 VDD.t161 VDD.t160 pfet_03v3 ad=3.52p pd=16.88u as=2.08p ps=8.52u w=8u l=0.28u
X180 VSS.t59 CLKN_H.t9 a_4812_41600.t6 VSS.t58 nfet_03v3 ad=2.08p pd=8.52u as=2.08p ps=8.52u w=8u l=0.28u
X181 VDD.t39 CLKN_HB.t5 a_2700_41600.t2 VDD.t38 pfet_03v3 ad=2.08p pd=8.52u as=2.08p ps=8.52u w=8u l=0.28u
X182 a_6924_41600.t1 CLKN_H.t18 VDD.t57 VDD.t56 pfet_03v3 ad=2.08p pd=8.52u as=2.08p ps=8.52u w=8u l=0.28u
X183 O_SENSE.t24 a_6924_41600.t24 VSS.t185 VSS.t184 nfet_03v3 ad=2.08p pd=8.52u as=2.08p ps=8.52u w=8u l=0.28u
X184 VDD.t145 CLKP_HB.t5 a_2700_6400.t2 VDD.t144 pfet_03v3 ad=2.08p pd=8.52u as=2.08p ps=8.52u w=8u l=0.28u
X185 VSS.t65 CLKN_H.t5 a_6924_41600.t10 VSS.t64 nfet_03v3 ad=2.08p pd=8.52u as=2.08p ps=8.52u w=8u l=0.28u
X186 VDD.t155 CLKP_H.t23 a_4812_6400.t0 VDD.t154 pfet_03v3 ad=2.08p pd=8.52u as=3.52p ps=16.88u w=8u l=0.28u
X187 VDD.t153 CLKP_H.t21 a_4812_6400.t2 VDD.t152 pfet_03v3 ad=2.08p pd=8.52u as=2.08p ps=8.52u w=8u l=0.28u
X188 VDD.t75 CLKN_H.t15 a_6924_41600.t4 VDD.t74 pfet_03v3 ad=2.08p pd=8.52u as=2.08p ps=8.52u w=8u l=0.28u
X189 VSS.t113 a_6924_41600.t21 O_SENSE.t8 VSS.t112 nfet_03v3 ad=2.08p pd=8.52u as=2.08p ps=8.52u w=8u l=0.28u
X190 E_SENSE.t2 a_6924_6400.t24 VSS.t3 VSS.t2 nfet_03v3 ad=2.08p pd=8.52u as=2.08p ps=8.52u w=8u l=0.28u
X191 a_6924_6400.t11 CLKP_H.t4 VSS.t151 VSS.t150 nfet_03v3 ad=2.08p pd=8.52u as=2.08p ps=8.52u w=8u l=0.28u
R0 E_SENSE E_SENSE.n30 8.89625
R1 E_SENSE.n30 E_SENSE.n14 6.5392
R2 E_SENSE.n16 E_SENSE.t15 5.7796
R3 E_SENSE.n1 E_SENSE.t27 5.73764
R4 E_SENSE.n29 E_SENSE.t26 5.59012
R5 E_SENSE.n14 E_SENSE.t0 5.54817
R6 E_SENSE.n16 E_SENSE.n15 5.38537
R7 E_SENSE.n18 E_SENSE.n17 5.38537
R8 E_SENSE.n20 E_SENSE.n19 5.38537
R9 E_SENSE.n22 E_SENSE.n21 5.38537
R10 E_SENSE.n24 E_SENSE.n23 5.38537
R11 E_SENSE.n26 E_SENSE.n25 5.38537
R12 E_SENSE.n28 E_SENSE.n27 5.38537
R13 E_SENSE.n1 E_SENSE.n0 5.32067
R14 E_SENSE.n3 E_SENSE.n2 5.32067
R15 E_SENSE.n5 E_SENSE.n4 5.32067
R16 E_SENSE.n7 E_SENSE.n6 5.32067
R17 E_SENSE.n9 E_SENSE.n8 5.32067
R18 E_SENSE.n11 E_SENSE.n10 5.32067
R19 E_SENSE.n13 E_SENSE.n12 5.32067
R20 E_SENSE.n30 E_SENSE.n29 4.61063
R21 E_SENSE.n0 E_SENSE.t14 0.228
R22 E_SENSE.n0 E_SENSE.t13 0.228
R23 E_SENSE.n2 E_SENSE.t23 0.228
R24 E_SENSE.n2 E_SENSE.t22 0.228
R25 E_SENSE.n4 E_SENSE.t19 0.228
R26 E_SENSE.n4 E_SENSE.t18 0.228
R27 E_SENSE.n6 E_SENSE.t29 0.228
R28 E_SENSE.n6 E_SENSE.t28 0.228
R29 E_SENSE.n8 E_SENSE.t17 0.228
R30 E_SENSE.n8 E_SENSE.t16 0.228
R31 E_SENSE.n10 E_SENSE.t10 0.228
R32 E_SENSE.n10 E_SENSE.t9 0.228
R33 E_SENSE.n12 E_SENSE.t4 0.228
R34 E_SENSE.n12 E_SENSE.t3 0.228
R35 E_SENSE.n15 E_SENSE.t12 0.20525
R36 E_SENSE.n15 E_SENSE.t11 0.20525
R37 E_SENSE.n17 E_SENSE.t6 0.20525
R38 E_SENSE.n17 E_SENSE.t5 0.20525
R39 E_SENSE.n19 E_SENSE.t25 0.20525
R40 E_SENSE.n19 E_SENSE.t24 0.20525
R41 E_SENSE.n21 E_SENSE.t2 0.20525
R42 E_SENSE.n21 E_SENSE.t1 0.20525
R43 E_SENSE.n23 E_SENSE.t8 0.20525
R44 E_SENSE.n23 E_SENSE.t7 0.20525
R45 E_SENSE.n25 E_SENSE.t21 0.20525
R46 E_SENSE.n25 E_SENSE.t20 0.20525
R47 E_SENSE.n27 E_SENSE.t31 0.20525
R48 E_SENSE.n27 E_SENSE.t30 0.20525
R49 E_SENSE.n29 E_SENSE.n28 0.189974
R50 E_SENSE.n28 E_SENSE.n26 0.189974
R51 E_SENSE.n26 E_SENSE.n24 0.189974
R52 E_SENSE.n24 E_SENSE.n22 0.189974
R53 E_SENSE.n22 E_SENSE.n20 0.189974
R54 E_SENSE.n20 E_SENSE.n18 0.189974
R55 E_SENSE.n18 E_SENSE.n16 0.189974
R56 E_SENSE.n14 E_SENSE.n13 0.189974
R57 E_SENSE.n13 E_SENSE.n11 0.189974
R58 E_SENSE.n11 E_SENSE.n9 0.189974
R59 E_SENSE.n9 E_SENSE.n7 0.189974
R60 E_SENSE.n7 E_SENSE.n5 0.189974
R61 E_SENSE.n5 E_SENSE.n3 0.189974
R62 E_SENSE.n3 E_SENSE.n1 0.189974
R63 E_CAPTURE_CLK E_CAPTURE_CLK.n14 6.63157
R64 E_CAPTURE_CLK.n14 E_CAPTURE_CLK.n6 6.5392
R65 E_CAPTURE_CLK.n8 E_CAPTURE_CLK.t4 5.7796
R66 E_CAPTURE_CLK.n1 E_CAPTURE_CLK.t8 5.73764
R67 E_CAPTURE_CLK.n13 E_CAPTURE_CLK.t15 5.59012
R68 E_CAPTURE_CLK.n6 E_CAPTURE_CLK.t1 5.54817
R69 E_CAPTURE_CLK.n8 E_CAPTURE_CLK.n7 5.38537
R70 E_CAPTURE_CLK.n10 E_CAPTURE_CLK.n9 5.38537
R71 E_CAPTURE_CLK.n12 E_CAPTURE_CLK.n11 5.38537
R72 E_CAPTURE_CLK.n1 E_CAPTURE_CLK.n0 5.32067
R73 E_CAPTURE_CLK.n3 E_CAPTURE_CLK.n2 5.32067
R74 E_CAPTURE_CLK.n5 E_CAPTURE_CLK.n4 5.32067
R75 E_CAPTURE_CLK.n14 E_CAPTURE_CLK.n13 4.61063
R76 E_CAPTURE_CLK.n0 E_CAPTURE_CLK.t6 0.228
R77 E_CAPTURE_CLK.n0 E_CAPTURE_CLK.t9 0.228
R78 E_CAPTURE_CLK.n2 E_CAPTURE_CLK.t2 0.228
R79 E_CAPTURE_CLK.n2 E_CAPTURE_CLK.t7 0.228
R80 E_CAPTURE_CLK.n4 E_CAPTURE_CLK.t0 0.228
R81 E_CAPTURE_CLK.n4 E_CAPTURE_CLK.t3 0.228
R82 E_CAPTURE_CLK.n7 E_CAPTURE_CLK.t12 0.20525
R83 E_CAPTURE_CLK.n7 E_CAPTURE_CLK.t5 0.20525
R84 E_CAPTURE_CLK.n9 E_CAPTURE_CLK.t10 0.20525
R85 E_CAPTURE_CLK.n9 E_CAPTURE_CLK.t13 0.20525
R86 E_CAPTURE_CLK.n11 E_CAPTURE_CLK.t14 0.20525
R87 E_CAPTURE_CLK.n11 E_CAPTURE_CLK.t11 0.20525
R88 E_CAPTURE_CLK.n13 E_CAPTURE_CLK.n12 0.189974
R89 E_CAPTURE_CLK.n12 E_CAPTURE_CLK.n10 0.189974
R90 E_CAPTURE_CLK.n10 E_CAPTURE_CLK.n8 0.189974
R91 E_CAPTURE_CLK.n6 E_CAPTURE_CLK.n5 0.189974
R92 E_CAPTURE_CLK.n5 E_CAPTURE_CLK.n3 0.189974
R93 E_CAPTURE_CLK.n3 E_CAPTURE_CLK.n1 0.189974
R94 E_CAPTURE_CLKB E_CAPTURE_CLKB.n14 6.96907
R95 E_CAPTURE_CLKB.n14 E_CAPTURE_CLKB.n6 6.5392
R96 E_CAPTURE_CLKB.n8 E_CAPTURE_CLKB.t0 5.7796
R97 E_CAPTURE_CLKB.n1 E_CAPTURE_CLKB.t15 5.73764
R98 E_CAPTURE_CLKB.n13 E_CAPTURE_CLKB.t14 5.59012
R99 E_CAPTURE_CLKB.n6 E_CAPTURE_CLKB.t5 5.54817
R100 E_CAPTURE_CLKB.n8 E_CAPTURE_CLKB.n7 5.38537
R101 E_CAPTURE_CLKB.n10 E_CAPTURE_CLKB.n9 5.38537
R102 E_CAPTURE_CLKB.n12 E_CAPTURE_CLKB.n11 5.38537
R103 E_CAPTURE_CLKB.n1 E_CAPTURE_CLKB.n0 5.32067
R104 E_CAPTURE_CLKB.n3 E_CAPTURE_CLKB.n2 5.32067
R105 E_CAPTURE_CLKB.n5 E_CAPTURE_CLKB.n4 5.32067
R106 E_CAPTURE_CLKB.n14 E_CAPTURE_CLKB.n13 4.61063
R107 E_CAPTURE_CLKB.n0 E_CAPTURE_CLKB.t4 0.228
R108 E_CAPTURE_CLKB.n0 E_CAPTURE_CLKB.t3 0.228
R109 E_CAPTURE_CLKB.n2 E_CAPTURE_CLKB.t2 0.228
R110 E_CAPTURE_CLKB.n2 E_CAPTURE_CLKB.t1 0.228
R111 E_CAPTURE_CLKB.n4 E_CAPTURE_CLKB.t9 0.228
R112 E_CAPTURE_CLKB.n4 E_CAPTURE_CLKB.t8 0.228
R113 E_CAPTURE_CLKB.n7 E_CAPTURE_CLKB.t7 0.20525
R114 E_CAPTURE_CLKB.n7 E_CAPTURE_CLKB.t6 0.20525
R115 E_CAPTURE_CLKB.n9 E_CAPTURE_CLKB.t13 0.20525
R116 E_CAPTURE_CLKB.n9 E_CAPTURE_CLKB.t12 0.20525
R117 E_CAPTURE_CLKB.n11 E_CAPTURE_CLKB.t11 0.20525
R118 E_CAPTURE_CLKB.n11 E_CAPTURE_CLKB.t10 0.20525
R119 E_CAPTURE_CLKB.n13 E_CAPTURE_CLKB.n12 0.189974
R120 E_CAPTURE_CLKB.n12 E_CAPTURE_CLKB.n10 0.189974
R121 E_CAPTURE_CLKB.n10 E_CAPTURE_CLKB.n8 0.189974
R122 E_CAPTURE_CLKB.n6 E_CAPTURE_CLKB.n5 0.189974
R123 E_CAPTURE_CLKB.n5 E_CAPTURE_CLKB.n3 0.189974
R124 E_CAPTURE_CLKB.n3 E_CAPTURE_CLKB.n1 0.189974
R125 CLKP_H.n15 CLKP_H.t7 113.632
R126 CLKP_H.n19 CLKP_H.t0 113.632
R127 CLKP_H.n2 CLKP_H.t19 113.632
R128 CLKP_H.n6 CLKP_H.t12 113.632
R129 CLKP_H.n35 CLKP_H.t11 113.632
R130 CLKP_H.n32 CLKP_H.t8 113.632
R131 CLKP_H.n27 CLKP_H.t20 113.632
R132 CLKP_H.n30 CLKP_H.t23 113.632
R133 CLKP_H.n22 CLKP_H.t3 109.174
R134 CLKP_H.n23 CLKP_H.t4 109.174
R135 CLKP_H.n16 CLKP_H.t6 109.174
R136 CLKP_H.n17 CLKP_H.t5 109.174
R137 CLKP_H.n21 CLKP_H.t2 109.174
R138 CLKP_H.n18 CLKP_H.t1 109.174
R139 CLKP_H.n9 CLKP_H.t15 109.174
R140 CLKP_H.n10 CLKP_H.t16 109.174
R141 CLKP_H.n3 CLKP_H.t18 109.174
R142 CLKP_H.n4 CLKP_H.t17 109.174
R143 CLKP_H.n8 CLKP_H.t14 109.174
R144 CLKP_H.n5 CLKP_H.t13 109.174
R145 CLKP_H.n33 CLKP_H.t9 109.174
R146 CLKP_H.n34 CLKP_H.t10 109.174
R147 CLKP_H.n28 CLKP_H.t21 109.174
R148 CLKP_H.n29 CLKP_H.t22 109.174
R149 CLKP_H.n22 CLKP_H.n13 18.4942
R150 CLKP_H.n24 CLKP_H.n23 18.4942
R151 CLKP_H.n17 CLKP_H.n14 18.4942
R152 CLKP_H.n21 CLKP_H.n20 18.4942
R153 CLKP_H.n9 CLKP_H.n0 18.4942
R154 CLKP_H.n11 CLKP_H.n10 18.4942
R155 CLKP_H.n4 CLKP_H.n1 18.4942
R156 CLKP_H.n8 CLKP_H.n7 18.4942
R157 CLKP_H.n38 CLKP_H.n26 15.3137
R158 CLKP_H.n38 CLKP_H.n37 14.6737
R159 CLKP_H.n22 CLKP_H.n21 11.6805
R160 CLKP_H.n23 CLKP_H.n22 11.6805
R161 CLKP_H.n17 CLKP_H.n16 11.6805
R162 CLKP_H.n23 CLKP_H.n17 11.6805
R163 CLKP_H.n21 CLKP_H.n18 11.6805
R164 CLKP_H.n9 CLKP_H.n8 11.6805
R165 CLKP_H.n10 CLKP_H.n9 11.6805
R166 CLKP_H.n4 CLKP_H.n3 11.6805
R167 CLKP_H.n10 CLKP_H.n4 11.6805
R168 CLKP_H.n8 CLKP_H.n5 11.6805
R169 CLKP_H.n34 CLKP_H.n33 11.6805
R170 CLKP_H.n29 CLKP_H.n28 11.6805
R171 CLKP_H.n26 CLKP_H.n12 10.9291
R172 CLKP_H.n37 CLKP_H.n31 10.9291
R173 CLKP_H.n26 CLKP_H.n25 9.0005
R174 CLKP_H.n37 CLKP_H.n36 9.0005
R175 CLKP_H.n20 CLKP_H.n19 7.17687
R176 CLKP_H.n15 CLKP_H.n14 7.17687
R177 CLKP_H.n7 CLKP_H.n6 7.17687
R178 CLKP_H.n2 CLKP_H.n1 7.17687
R179 CLKP_H.n36 CLKP_H.n32 7.10487
R180 CLKP_H.n36 CLKP_H.n35 7.10487
R181 CLKP_H.n31 CLKP_H.n27 7.10487
R182 CLKP_H.n31 CLKP_H.n30 7.10487
R183 CLKP_H.n16 CLKP_H.n15 4.42851
R184 CLKP_H.n19 CLKP_H.n18 4.42851
R185 CLKP_H.n3 CLKP_H.n2 4.42851
R186 CLKP_H.n6 CLKP_H.n5 4.42851
R187 CLKP_H.n33 CLKP_H.n32 4.42851
R188 CLKP_H.n35 CLKP_H.n34 4.42851
R189 CLKP_H.n28 CLKP_H.n27 4.42851
R190 CLKP_H.n30 CLKP_H.n29 4.42851
R191 CLKP_H CLKP_H.n38 0.714184
R192 CLKP_H.n20 CLKP_H.n13 0.1205
R193 CLKP_H.n24 CLKP_H.n14 0.1205
R194 CLKP_H.n7 CLKP_H.n0 0.1205
R195 CLKP_H.n11 CLKP_H.n1 0.1205
R196 CLKP_H.n25 CLKP_H.n13 0.0485
R197 CLKP_H.n25 CLKP_H.n24 0.0485
R198 CLKP_H.n12 CLKP_H.n0 0.0485
R199 CLKP_H.n12 CLKP_H.n11 0.0485
R200 CLKP_HB.n8 CLKP_HB.t3 113.632
R201 CLKP_HB.n5 CLKP_HB.t0 113.632
R202 CLKP_HB.n0 CLKP_HB.t4 113.632
R203 CLKP_HB.n3 CLKP_HB.t7 113.632
R204 CLKP_HB.n6 CLKP_HB.t1 109.174
R205 CLKP_HB.n7 CLKP_HB.t2 109.174
R206 CLKP_HB.n1 CLKP_HB.t5 109.174
R207 CLKP_HB.n2 CLKP_HB.t6 109.174
R208 CLKP_HB CLKP_HB.n10 12.85
R209 CLKP_HB.n7 CLKP_HB.n6 11.6805
R210 CLKP_HB.n2 CLKP_HB.n1 11.6805
R211 CLKP_HB.n10 CLKP_HB.n4 10.9291
R212 CLKP_HB.n10 CLKP_HB.n9 9.0005
R213 CLKP_HB.n9 CLKP_HB.n5 7.10487
R214 CLKP_HB.n9 CLKP_HB.n8 7.10487
R215 CLKP_HB.n4 CLKP_HB.n0 7.10487
R216 CLKP_HB.n4 CLKP_HB.n3 7.10487
R217 CLKP_HB.n6 CLKP_HB.n5 4.42851
R218 CLKP_HB.n8 CLKP_HB.n7 4.42851
R219 CLKP_HB.n1 CLKP_HB.n0 4.42851
R220 CLKP_HB.n3 CLKP_HB.n2 4.42851
R221 O_SENSE O_SENSE.n30 8.89625
R222 O_SENSE.n30 O_SENSE.n14 6.5392
R223 O_SENSE.n16 O_SENSE.t31 5.7796
R224 O_SENSE.n1 O_SENSE.t5 5.73764
R225 O_SENSE.n29 O_SENSE.t4 5.59012
R226 O_SENSE.n14 O_SENSE.t14 5.54817
R227 O_SENSE.n16 O_SENSE.n15 5.38537
R228 O_SENSE.n18 O_SENSE.n17 5.38537
R229 O_SENSE.n20 O_SENSE.n19 5.38537
R230 O_SENSE.n22 O_SENSE.n21 5.38537
R231 O_SENSE.n24 O_SENSE.n23 5.38537
R232 O_SENSE.n26 O_SENSE.n25 5.38537
R233 O_SENSE.n28 O_SENSE.n27 5.38537
R234 O_SENSE.n1 O_SENSE.n0 5.32067
R235 O_SENSE.n3 O_SENSE.n2 5.32067
R236 O_SENSE.n5 O_SENSE.n4 5.32067
R237 O_SENSE.n7 O_SENSE.n6 5.32067
R238 O_SENSE.n9 O_SENSE.n8 5.32067
R239 O_SENSE.n11 O_SENSE.n10 5.32067
R240 O_SENSE.n13 O_SENSE.n12 5.32067
R241 O_SENSE.n30 O_SENSE.n29 4.61063
R242 O_SENSE.n0 O_SENSE.t30 0.228
R243 O_SENSE.n0 O_SENSE.t29 0.228
R244 O_SENSE.n2 O_SENSE.t1 0.228
R245 O_SENSE.n2 O_SENSE.t0 0.228
R246 O_SENSE.n4 O_SENSE.t20 0.228
R247 O_SENSE.n4 O_SENSE.t19 0.228
R248 O_SENSE.n6 O_SENSE.t16 0.228
R249 O_SENSE.n6 O_SENSE.t15 0.228
R250 O_SENSE.n8 O_SENSE.t11 0.228
R251 O_SENSE.n8 O_SENSE.t10 0.228
R252 O_SENSE.n10 O_SENSE.t7 0.228
R253 O_SENSE.n10 O_SENSE.t6 0.228
R254 O_SENSE.n12 O_SENSE.t26 0.228
R255 O_SENSE.n12 O_SENSE.t25 0.228
R256 O_SENSE.n15 O_SENSE.t3 0.20525
R257 O_SENSE.n15 O_SENSE.t2 0.20525
R258 O_SENSE.n17 O_SENSE.t22 0.20525
R259 O_SENSE.n17 O_SENSE.t21 0.20525
R260 O_SENSE.n19 O_SENSE.t9 0.20525
R261 O_SENSE.n19 O_SENSE.t8 0.20525
R262 O_SENSE.n21 O_SENSE.t24 0.20525
R263 O_SENSE.n21 O_SENSE.t23 0.20525
R264 O_SENSE.n23 O_SENSE.t18 0.20525
R265 O_SENSE.n23 O_SENSE.t17 0.20525
R266 O_SENSE.n25 O_SENSE.t13 0.20525
R267 O_SENSE.n25 O_SENSE.t12 0.20525
R268 O_SENSE.n27 O_SENSE.t28 0.20525
R269 O_SENSE.n27 O_SENSE.t27 0.20525
R270 O_SENSE.n29 O_SENSE.n28 0.189974
R271 O_SENSE.n28 O_SENSE.n26 0.189974
R272 O_SENSE.n26 O_SENSE.n24 0.189974
R273 O_SENSE.n24 O_SENSE.n22 0.189974
R274 O_SENSE.n22 O_SENSE.n20 0.189974
R275 O_SENSE.n20 O_SENSE.n18 0.189974
R276 O_SENSE.n18 O_SENSE.n16 0.189974
R277 O_SENSE.n14 O_SENSE.n13 0.189974
R278 O_SENSE.n13 O_SENSE.n11 0.189974
R279 O_SENSE.n11 O_SENSE.n9 0.189974
R280 O_SENSE.n9 O_SENSE.n7 0.189974
R281 O_SENSE.n7 O_SENSE.n5 0.189974
R282 O_SENSE.n5 O_SENSE.n3 0.189974
R283 O_SENSE.n3 O_SENSE.n1 0.189974
R284 O_CAPTURE_CLK O_CAPTURE_CLK.n14 6.63157
R285 O_CAPTURE_CLK.n14 O_CAPTURE_CLK.n6 6.5392
R286 O_CAPTURE_CLK.n8 O_CAPTURE_CLK.t12 5.7796
R287 O_CAPTURE_CLK.n1 O_CAPTURE_CLK.t4 5.73764
R288 O_CAPTURE_CLK.n13 O_CAPTURE_CLK.t11 5.59012
R289 O_CAPTURE_CLK.n6 O_CAPTURE_CLK.t3 5.54817
R290 O_CAPTURE_CLK.n8 O_CAPTURE_CLK.n7 5.38537
R291 O_CAPTURE_CLK.n10 O_CAPTURE_CLK.n9 5.38537
R292 O_CAPTURE_CLK.n12 O_CAPTURE_CLK.n11 5.38537
R293 O_CAPTURE_CLK.n1 O_CAPTURE_CLK.n0 5.32067
R294 O_CAPTURE_CLK.n3 O_CAPTURE_CLK.n2 5.32067
R295 O_CAPTURE_CLK.n5 O_CAPTURE_CLK.n4 5.32067
R296 O_CAPTURE_CLK.n14 O_CAPTURE_CLK.n13 4.61063
R297 O_CAPTURE_CLK.n0 O_CAPTURE_CLK.t8 0.228
R298 O_CAPTURE_CLK.n0 O_CAPTURE_CLK.t5 0.228
R299 O_CAPTURE_CLK.n2 O_CAPTURE_CLK.t14 0.228
R300 O_CAPTURE_CLK.n2 O_CAPTURE_CLK.t9 0.228
R301 O_CAPTURE_CLK.n4 O_CAPTURE_CLK.t2 0.228
R302 O_CAPTURE_CLK.n4 O_CAPTURE_CLK.t15 0.228
R303 O_CAPTURE_CLK.n7 O_CAPTURE_CLK.t0 0.20525
R304 O_CAPTURE_CLK.n7 O_CAPTURE_CLK.t13 0.20525
R305 O_CAPTURE_CLK.n9 O_CAPTURE_CLK.t6 0.20525
R306 O_CAPTURE_CLK.n9 O_CAPTURE_CLK.t1 0.20525
R307 O_CAPTURE_CLK.n11 O_CAPTURE_CLK.t10 0.20525
R308 O_CAPTURE_CLK.n11 O_CAPTURE_CLK.t7 0.20525
R309 O_CAPTURE_CLK.n13 O_CAPTURE_CLK.n12 0.189974
R310 O_CAPTURE_CLK.n12 O_CAPTURE_CLK.n10 0.189974
R311 O_CAPTURE_CLK.n10 O_CAPTURE_CLK.n8 0.189974
R312 O_CAPTURE_CLK.n6 O_CAPTURE_CLK.n5 0.189974
R313 O_CAPTURE_CLK.n5 O_CAPTURE_CLK.n3 0.189974
R314 O_CAPTURE_CLK.n3 O_CAPTURE_CLK.n1 0.189974
R315 O_CAPTURE_CLKB O_CAPTURE_CLKB.n14 6.96907
R316 O_CAPTURE_CLKB.n14 O_CAPTURE_CLKB.n6 6.5392
R317 O_CAPTURE_CLKB.n8 O_CAPTURE_CLKB.t13 5.7796
R318 O_CAPTURE_CLKB.n1 O_CAPTURE_CLKB.t15 5.73764
R319 O_CAPTURE_CLKB.n13 O_CAPTURE_CLKB.t14 5.59012
R320 O_CAPTURE_CLKB.n6 O_CAPTURE_CLKB.t3 5.54817
R321 O_CAPTURE_CLKB.n8 O_CAPTURE_CLKB.n7 5.38537
R322 O_CAPTURE_CLKB.n10 O_CAPTURE_CLKB.n9 5.38537
R323 O_CAPTURE_CLKB.n12 O_CAPTURE_CLKB.n11 5.38537
R324 O_CAPTURE_CLKB.n1 O_CAPTURE_CLKB.n0 5.32067
R325 O_CAPTURE_CLKB.n3 O_CAPTURE_CLKB.n2 5.32067
R326 O_CAPTURE_CLKB.n5 O_CAPTURE_CLKB.n4 5.32067
R327 O_CAPTURE_CLKB.n14 O_CAPTURE_CLKB.n13 4.61063
R328 O_CAPTURE_CLKB.n0 O_CAPTURE_CLKB.t8 0.228
R329 O_CAPTURE_CLKB.n0 O_CAPTURE_CLKB.t7 0.228
R330 O_CAPTURE_CLKB.n2 O_CAPTURE_CLKB.t6 0.228
R331 O_CAPTURE_CLKB.n2 O_CAPTURE_CLKB.t5 0.228
R332 O_CAPTURE_CLKB.n4 O_CAPTURE_CLKB.t10 0.228
R333 O_CAPTURE_CLKB.n4 O_CAPTURE_CLKB.t9 0.228
R334 O_CAPTURE_CLKB.n7 O_CAPTURE_CLKB.t4 0.20525
R335 O_CAPTURE_CLKB.n7 O_CAPTURE_CLKB.t2 0.20525
R336 O_CAPTURE_CLKB.n9 O_CAPTURE_CLKB.t1 0.20525
R337 O_CAPTURE_CLKB.n9 O_CAPTURE_CLKB.t0 0.20525
R338 O_CAPTURE_CLKB.n11 O_CAPTURE_CLKB.t12 0.20525
R339 O_CAPTURE_CLKB.n11 O_CAPTURE_CLKB.t11 0.20525
R340 O_CAPTURE_CLKB.n13 O_CAPTURE_CLKB.n12 0.189974
R341 O_CAPTURE_CLKB.n12 O_CAPTURE_CLKB.n10 0.189974
R342 O_CAPTURE_CLKB.n10 O_CAPTURE_CLKB.n8 0.189974
R343 O_CAPTURE_CLKB.n6 O_CAPTURE_CLKB.n5 0.189974
R344 O_CAPTURE_CLKB.n5 O_CAPTURE_CLKB.n3 0.189974
R345 O_CAPTURE_CLKB.n3 O_CAPTURE_CLKB.n1 0.189974
R346 CLKN_H.n15 CLKN_H.t7 113.632
R347 CLKN_H.n19 CLKN_H.t0 113.632
R348 CLKN_H.n2 CLKN_H.t19 113.632
R349 CLKN_H.n6 CLKN_H.t12 113.632
R350 CLKN_H.n35 CLKN_H.t11 113.632
R351 CLKN_H.n32 CLKN_H.t8 113.632
R352 CLKN_H.n27 CLKN_H.t20 113.632
R353 CLKN_H.n30 CLKN_H.t23 113.632
R354 CLKN_H.n22 CLKN_H.t3 109.174
R355 CLKN_H.n23 CLKN_H.t4 109.174
R356 CLKN_H.n16 CLKN_H.t6 109.174
R357 CLKN_H.n17 CLKN_H.t5 109.174
R358 CLKN_H.n21 CLKN_H.t2 109.174
R359 CLKN_H.n18 CLKN_H.t1 109.174
R360 CLKN_H.n9 CLKN_H.t15 109.174
R361 CLKN_H.n10 CLKN_H.t16 109.174
R362 CLKN_H.n3 CLKN_H.t18 109.174
R363 CLKN_H.n4 CLKN_H.t17 109.174
R364 CLKN_H.n8 CLKN_H.t14 109.174
R365 CLKN_H.n5 CLKN_H.t13 109.174
R366 CLKN_H.n33 CLKN_H.t9 109.174
R367 CLKN_H.n34 CLKN_H.t10 109.174
R368 CLKN_H.n28 CLKN_H.t21 109.174
R369 CLKN_H.n29 CLKN_H.t22 109.174
R370 CLKN_H.n22 CLKN_H.n13 18.4942
R371 CLKN_H.n24 CLKN_H.n23 18.4942
R372 CLKN_H.n17 CLKN_H.n14 18.4942
R373 CLKN_H.n21 CLKN_H.n20 18.4942
R374 CLKN_H.n9 CLKN_H.n0 18.4942
R375 CLKN_H.n11 CLKN_H.n10 18.4942
R376 CLKN_H.n4 CLKN_H.n1 18.4942
R377 CLKN_H.n8 CLKN_H.n7 18.4942
R378 CLKN_H.n38 CLKN_H.n26 15.3137
R379 CLKN_H.n38 CLKN_H.n37 14.6737
R380 CLKN_H.n22 CLKN_H.n21 11.6805
R381 CLKN_H.n23 CLKN_H.n22 11.6805
R382 CLKN_H.n17 CLKN_H.n16 11.6805
R383 CLKN_H.n23 CLKN_H.n17 11.6805
R384 CLKN_H.n21 CLKN_H.n18 11.6805
R385 CLKN_H.n9 CLKN_H.n8 11.6805
R386 CLKN_H.n10 CLKN_H.n9 11.6805
R387 CLKN_H.n4 CLKN_H.n3 11.6805
R388 CLKN_H.n10 CLKN_H.n4 11.6805
R389 CLKN_H.n8 CLKN_H.n5 11.6805
R390 CLKN_H.n34 CLKN_H.n33 11.6805
R391 CLKN_H.n29 CLKN_H.n28 11.6805
R392 CLKN_H.n26 CLKN_H.n12 10.9291
R393 CLKN_H.n37 CLKN_H.n31 10.9291
R394 CLKN_H.n26 CLKN_H.n25 9.0005
R395 CLKN_H.n37 CLKN_H.n36 9.0005
R396 CLKN_H.n20 CLKN_H.n19 7.17687
R397 CLKN_H.n15 CLKN_H.n14 7.17687
R398 CLKN_H.n7 CLKN_H.n6 7.17687
R399 CLKN_H.n2 CLKN_H.n1 7.17687
R400 CLKN_H.n36 CLKN_H.n32 7.10487
R401 CLKN_H.n36 CLKN_H.n35 7.10487
R402 CLKN_H.n31 CLKN_H.n27 7.10487
R403 CLKN_H.n31 CLKN_H.n30 7.10487
R404 CLKN_H.n16 CLKN_H.n15 4.42851
R405 CLKN_H.n19 CLKN_H.n18 4.42851
R406 CLKN_H.n3 CLKN_H.n2 4.42851
R407 CLKN_H.n6 CLKN_H.n5 4.42851
R408 CLKN_H.n33 CLKN_H.n32 4.42851
R409 CLKN_H.n35 CLKN_H.n34 4.42851
R410 CLKN_H.n28 CLKN_H.n27 4.42851
R411 CLKN_H.n30 CLKN_H.n29 4.42851
R412 CLKN_H CLKN_H.n38 0.714184
R413 CLKN_H.n20 CLKN_H.n13 0.1205
R414 CLKN_H.n24 CLKN_H.n14 0.1205
R415 CLKN_H.n7 CLKN_H.n0 0.1205
R416 CLKN_H.n11 CLKN_H.n1 0.1205
R417 CLKN_H.n25 CLKN_H.n13 0.0485
R418 CLKN_H.n25 CLKN_H.n24 0.0485
R419 CLKN_H.n12 CLKN_H.n0 0.0485
R420 CLKN_H.n12 CLKN_H.n11 0.0485
R421 CLKN_HB.n8 CLKN_HB.t3 113.632
R422 CLKN_HB.n5 CLKN_HB.t0 113.632
R423 CLKN_HB.n0 CLKN_HB.t4 113.632
R424 CLKN_HB.n3 CLKN_HB.t7 113.632
R425 CLKN_HB.n6 CLKN_HB.t1 109.174
R426 CLKN_HB.n7 CLKN_HB.t2 109.174
R427 CLKN_HB.n1 CLKN_HB.t5 109.174
R428 CLKN_HB.n2 CLKN_HB.t6 109.174
R429 CLKN_HB CLKN_HB.n10 13.6326
R430 CLKN_HB.n7 CLKN_HB.n6 11.6805
R431 CLKN_HB.n2 CLKN_HB.n1 11.6805
R432 CLKN_HB.n10 CLKN_HB.n4 10.9291
R433 CLKN_HB.n10 CLKN_HB.n9 9.0005
R434 CLKN_HB.n9 CLKN_HB.n5 7.10487
R435 CLKN_HB.n9 CLKN_HB.n8 7.10487
R436 CLKN_HB.n4 CLKN_HB.n0 7.10487
R437 CLKN_HB.n4 CLKN_HB.n3 7.10487
R438 CLKN_HB.n6 CLKN_HB.n5 4.42851
R439 CLKN_HB.n8 CLKN_HB.n7 4.42851
R440 CLKN_HB.n1 CLKN_HB.n0 4.42851
R441 CLKN_HB.n3 CLKN_HB.n2 4.42851
R442 VDD.t60 VDD.t32 450.829
R443 VDD.t66 VDD.t64 450.829
R444 VDD.t18 VDD.t72 450.829
R445 VDD.t12 VDD.t180 450.829
R446 VDD.t134 VDD.t14 450.829
R447 VDD.t154 VDD.t146 450.829
R448 VDD.t162 VDD.t160 450.829
R449 VDD.t108 VDD.t150 450.829
R450 VDD.t8 VDD.t182 450.829
R451 VDD.t0 VDD.t92 450.829
R452 VDD.t34 VDD.n55 417.582
R453 VDD.t140 VDD.n1 417.582
R454 VDD.n56 VDD.t122 165.653
R455 VDD.n2 VDD.t124 165.653
R456 VDD.t36 VDD.t34 44.1994
R457 VDD.t38 VDD.t36 44.1994
R458 VDD.t32 VDD.t38 44.1994
R459 VDD.t62 VDD.t60 44.1994
R460 VDD.t58 VDD.t62 44.1994
R461 VDD.t64 VDD.t58 44.1994
R462 VDD.t56 VDD.t66 44.1994
R463 VDD.t68 VDD.t56 44.1994
R464 VDD.t70 VDD.t68 44.1994
R465 VDD.t74 VDD.t70 44.1994
R466 VDD.t76 VDD.t74 44.1994
R467 VDD.t78 VDD.t76 44.1994
R468 VDD.t72 VDD.t78 44.1994
R469 VDD.t102 VDD.t18 44.1994
R470 VDD.t100 VDD.t102 44.1994
R471 VDD.t54 VDD.t100 44.1994
R472 VDD.t52 VDD.t54 44.1994
R473 VDD.t82 VDD.t52 44.1994
R474 VDD.t80 VDD.t82 44.1994
R475 VDD.t180 VDD.t80 44.1994
R476 VDD.t10 VDD.t12 44.1994
R477 VDD.t98 VDD.t10 44.1994
R478 VDD.t96 VDD.t98 44.1994
R479 VDD.t22 VDD.t96 44.1994
R480 VDD.t20 VDD.t22 44.1994
R481 VDD.t16 VDD.t20 44.1994
R482 VDD.t14 VDD.t16 44.1994
R483 VDD.t186 VDD.t134 44.1994
R484 VDD.t184 VDD.t186 44.1994
R485 VDD.t128 VDD.t184 44.1994
R486 VDD.t126 VDD.t128 44.1994
R487 VDD.t132 VDD.t126 44.1994
R488 VDD.t130 VDD.t132 44.1994
R489 VDD.t138 VDD.t130 44.1994
R490 VDD.t136 VDD.t138 44.1994
R491 VDD.t178 VDD.t136 44.1994
R492 VDD.t176 VDD.t178 44.1994
R493 VDD.t112 VDD.t176 44.1994
R494 VDD.t110 VDD.t112 44.1994
R495 VDD.t190 VDD.t110 44.1994
R496 VDD.t188 VDD.t190 44.1994
R497 VDD.t122 VDD.t188 44.1994
R498 VDD.t142 VDD.t140 44.1994
R499 VDD.t144 VDD.t142 44.1994
R500 VDD.t146 VDD.t144 44.1994
R501 VDD.t158 VDD.t154 44.1994
R502 VDD.t152 VDD.t158 44.1994
R503 VDD.t160 VDD.t152 44.1994
R504 VDD.t148 VDD.t162 44.1994
R505 VDD.t164 VDD.t148 44.1994
R506 VDD.t166 VDD.t164 44.1994
R507 VDD.t156 VDD.t166 44.1994
R508 VDD.t168 VDD.t156 44.1994
R509 VDD.t170 VDD.t168 44.1994
R510 VDD.t150 VDD.t170 44.1994
R511 VDD.t120 VDD.t108 44.1994
R512 VDD.t118 VDD.t120 44.1994
R513 VDD.t42 VDD.t118 44.1994
R514 VDD.t40 VDD.t42 44.1994
R515 VDD.t50 VDD.t40 44.1994
R516 VDD.t48 VDD.t50 44.1994
R517 VDD.t182 VDD.t48 44.1994
R518 VDD.t6 VDD.t8 44.1994
R519 VDD.t30 VDD.t6 44.1994
R520 VDD.t28 VDD.t30 44.1994
R521 VDD.t86 VDD.t28 44.1994
R522 VDD.t84 VDD.t86 44.1994
R523 VDD.t94 VDD.t84 44.1994
R524 VDD.t92 VDD.t94 44.1994
R525 VDD.t4 VDD.t0 44.1994
R526 VDD.t2 VDD.t4 44.1994
R527 VDD.t26 VDD.t2 44.1994
R528 VDD.t24 VDD.t26 44.1994
R529 VDD.t90 VDD.t24 44.1994
R530 VDD.t88 VDD.t90 44.1994
R531 VDD.t174 VDD.t88 44.1994
R532 VDD.t172 VDD.t174 44.1994
R533 VDD.t106 VDD.t172 44.1994
R534 VDD.t104 VDD.t106 44.1994
R535 VDD.t116 VDD.t104 44.1994
R536 VDD.t114 VDD.t116 44.1994
R537 VDD.t46 VDD.t114 44.1994
R538 VDD.t44 VDD.t46 44.1994
R539 VDD.t124 VDD.t44 44.1994
R540 VDD.n72 VDD.n71 11.1661
R541 VDD.n80 VDD.n79 11.1661
R542 VDD.n88 VDD.n87 11.1661
R543 VDD.n96 VDD.n95 11.1661
R544 VDD.n100 VDD.n99 11.1661
R545 VDD.n104 VDD.n103 11.1661
R546 VDD.n18 VDD.n17 11.1661
R547 VDD.n26 VDD.n25 11.1661
R548 VDD.n34 VDD.n33 11.1661
R549 VDD.n42 VDD.n41 11.1661
R550 VDD.n46 VDD.n45 11.1661
R551 VDD.n50 VDD.n49 11.1661
R552 VDD.n59 VDD.n57 5.51014
R553 VDD.n75 VDD.n73 5.51014
R554 VDD.n83 VDD.n81 5.51014
R555 VDD.n91 VDD.n89 5.51014
R556 VDD.n99 VDD.n97 5.51014
R557 VDD.n103 VDD.n101 5.51014
R558 VDD.n5 VDD.n3 5.51014
R559 VDD.n21 VDD.n19 5.51014
R560 VDD.n29 VDD.n27 5.51014
R561 VDD.n37 VDD.n35 5.51014
R562 VDD.n45 VDD.n43 5.51014
R563 VDD.n49 VDD.n47 5.51014
R564 VDD.n71 VDD.n70 5.32067
R565 VDD.n69 VDD.n68 5.32067
R566 VDD.n67 VDD.n66 5.32067
R567 VDD.n65 VDD.n64 5.32067
R568 VDD.n63 VDD.n62 5.32067
R569 VDD.n61 VDD.n60 5.32067
R570 VDD.n59 VDD.n58 5.32067
R571 VDD.n79 VDD.n78 5.32067
R572 VDD.n77 VDD.n76 5.32067
R573 VDD.n75 VDD.n74 5.32067
R574 VDD.n87 VDD.n86 5.32067
R575 VDD.n85 VDD.n84 5.32067
R576 VDD.n83 VDD.n82 5.32067
R577 VDD.n95 VDD.n94 5.32067
R578 VDD.n93 VDD.n92 5.32067
R579 VDD.n91 VDD.n90 5.32067
R580 VDD.n99 VDD.n98 5.32067
R581 VDD.n103 VDD.n102 5.32067
R582 VDD.n17 VDD.n16 5.32067
R583 VDD.n15 VDD.n14 5.32067
R584 VDD.n13 VDD.n12 5.32067
R585 VDD.n11 VDD.n10 5.32067
R586 VDD.n9 VDD.n8 5.32067
R587 VDD.n7 VDD.n6 5.32067
R588 VDD.n5 VDD.n4 5.32067
R589 VDD.n25 VDD.n24 5.32067
R590 VDD.n23 VDD.n22 5.32067
R591 VDD.n21 VDD.n20 5.32067
R592 VDD.n33 VDD.n32 5.32067
R593 VDD.n31 VDD.n30 5.32067
R594 VDD.n29 VDD.n28 5.32067
R595 VDD.n41 VDD.n40 5.32067
R596 VDD.n39 VDD.n38 5.32067
R597 VDD.n37 VDD.n36 5.32067
R598 VDD.n45 VDD.n44 5.32067
R599 VDD.n49 VDD.n48 5.32067
R600 VDD.n54 VDD.n0 4.5005
R601 VDD.n108 VDD.n0 4.5005
R602 VDD.n54 VDD.n53 3.31026
R603 VDD.n108 VDD.n107 2.76928
R604 VDD.n110 VDD.n109 2.26839
R605 VDD.n107 VDD.n106 2.2545
R606 VDD.n53 VDD.n52 2.2545
R607 VDD.n106 VDD.n105 2.2505
R608 VDD.n52 VDD.n51 2.2505
R609 VDD.n106 VDD.n56 1.68318
R610 VDD.n52 VDD.n2 1.68318
R611 VDD VDD.n110 1.13544
R612 VDD.n80 VDD.n72 0.4541
R613 VDD.n26 VDD.n18 0.4541
R614 VDD.n100 VDD.n96 0.3101
R615 VDD.n96 VDD.n88 0.3101
R616 VDD.n88 VDD.n80 0.3101
R617 VDD.n46 VDD.n42 0.3101
R618 VDD.n42 VDD.n34 0.3101
R619 VDD.n34 VDD.n26 0.3101
R620 VDD.n104 VDD.n100 0.2381
R621 VDD.n50 VDD.n46 0.2381
R622 VDD.n105 VDD.n104 0.236975
R623 VDD.n51 VDD.n50 0.236975
R624 VDD.n70 VDD.t189 0.228
R625 VDD.n70 VDD.t123 0.228
R626 VDD.n68 VDD.t111 0.228
R627 VDD.n68 VDD.t191 0.228
R628 VDD.n66 VDD.t177 0.228
R629 VDD.n66 VDD.t113 0.228
R630 VDD.n64 VDD.t137 0.228
R631 VDD.n64 VDD.t179 0.228
R632 VDD.n62 VDD.t131 0.228
R633 VDD.n62 VDD.t139 0.228
R634 VDD.n60 VDD.t127 0.228
R635 VDD.n60 VDD.t133 0.228
R636 VDD.n58 VDD.t185 0.228
R637 VDD.n58 VDD.t129 0.228
R638 VDD.n57 VDD.t135 0.228
R639 VDD.n57 VDD.t187 0.228
R640 VDD.n78 VDD.t17 0.228
R641 VDD.n78 VDD.t15 0.228
R642 VDD.n76 VDD.t23 0.228
R643 VDD.n76 VDD.t21 0.228
R644 VDD.n74 VDD.t99 0.228
R645 VDD.n74 VDD.t97 0.228
R646 VDD.n73 VDD.t13 0.228
R647 VDD.n73 VDD.t11 0.228
R648 VDD.n86 VDD.t81 0.228
R649 VDD.n86 VDD.t181 0.228
R650 VDD.n84 VDD.t53 0.228
R651 VDD.n84 VDD.t83 0.228
R652 VDD.n82 VDD.t101 0.228
R653 VDD.n82 VDD.t55 0.228
R654 VDD.n81 VDD.t19 0.228
R655 VDD.n81 VDD.t103 0.228
R656 VDD.n94 VDD.t79 0.228
R657 VDD.n94 VDD.t73 0.228
R658 VDD.n92 VDD.t75 0.228
R659 VDD.n92 VDD.t77 0.228
R660 VDD.n90 VDD.t69 0.228
R661 VDD.n90 VDD.t71 0.228
R662 VDD.n89 VDD.t67 0.228
R663 VDD.n89 VDD.t57 0.228
R664 VDD.n98 VDD.t59 0.228
R665 VDD.n98 VDD.t65 0.228
R666 VDD.n97 VDD.t61 0.228
R667 VDD.n97 VDD.t63 0.228
R668 VDD.n102 VDD.t39 0.228
R669 VDD.n102 VDD.t33 0.228
R670 VDD.n101 VDD.t35 0.228
R671 VDD.n101 VDD.t37 0.228
R672 VDD.n16 VDD.t45 0.228
R673 VDD.n16 VDD.t125 0.228
R674 VDD.n14 VDD.t115 0.228
R675 VDD.n14 VDD.t47 0.228
R676 VDD.n12 VDD.t105 0.228
R677 VDD.n12 VDD.t117 0.228
R678 VDD.n10 VDD.t173 0.228
R679 VDD.n10 VDD.t107 0.228
R680 VDD.n8 VDD.t89 0.228
R681 VDD.n8 VDD.t175 0.228
R682 VDD.n6 VDD.t25 0.228
R683 VDD.n6 VDD.t91 0.228
R684 VDD.n4 VDD.t3 0.228
R685 VDD.n4 VDD.t27 0.228
R686 VDD.n3 VDD.t1 0.228
R687 VDD.n3 VDD.t5 0.228
R688 VDD.n24 VDD.t95 0.228
R689 VDD.n24 VDD.t93 0.228
R690 VDD.n22 VDD.t87 0.228
R691 VDD.n22 VDD.t85 0.228
R692 VDD.n20 VDD.t31 0.228
R693 VDD.n20 VDD.t29 0.228
R694 VDD.n19 VDD.t9 0.228
R695 VDD.n19 VDD.t7 0.228
R696 VDD.n32 VDD.t49 0.228
R697 VDD.n32 VDD.t183 0.228
R698 VDD.n30 VDD.t41 0.228
R699 VDD.n30 VDD.t51 0.228
R700 VDD.n28 VDD.t119 0.228
R701 VDD.n28 VDD.t43 0.228
R702 VDD.n27 VDD.t109 0.228
R703 VDD.n27 VDD.t121 0.228
R704 VDD.n40 VDD.t171 0.228
R705 VDD.n40 VDD.t151 0.228
R706 VDD.n38 VDD.t157 0.228
R707 VDD.n38 VDD.t169 0.228
R708 VDD.n36 VDD.t165 0.228
R709 VDD.n36 VDD.t167 0.228
R710 VDD.n35 VDD.t163 0.228
R711 VDD.n35 VDD.t149 0.228
R712 VDD.n44 VDD.t153 0.228
R713 VDD.n44 VDD.t161 0.228
R714 VDD.n43 VDD.t155 0.228
R715 VDD.n43 VDD.t159 0.228
R716 VDD.n48 VDD.t145 0.228
R717 VDD.n48 VDD.t147 0.228
R718 VDD.n47 VDD.t141 0.228
R719 VDD.n47 VDD.t143 0.228
R720 VDD.n61 VDD.n59 0.189974
R721 VDD.n63 VDD.n61 0.189974
R722 VDD.n65 VDD.n63 0.189974
R723 VDD.n67 VDD.n65 0.189974
R724 VDD.n69 VDD.n67 0.189974
R725 VDD.n71 VDD.n69 0.189974
R726 VDD.n77 VDD.n75 0.189974
R727 VDD.n79 VDD.n77 0.189974
R728 VDD.n85 VDD.n83 0.189974
R729 VDD.n87 VDD.n85 0.189974
R730 VDD.n93 VDD.n91 0.189974
R731 VDD.n95 VDD.n93 0.189974
R732 VDD.n7 VDD.n5 0.189974
R733 VDD.n9 VDD.n7 0.189974
R734 VDD.n11 VDD.n9 0.189974
R735 VDD.n13 VDD.n11 0.189974
R736 VDD.n15 VDD.n13 0.189974
R737 VDD.n17 VDD.n15 0.189974
R738 VDD.n23 VDD.n21 0.189974
R739 VDD.n25 VDD.n23 0.189974
R740 VDD.n31 VDD.n29 0.189974
R741 VDD.n33 VDD.n31 0.189974
R742 VDD.n39 VDD.n37 0.189974
R743 VDD.n41 VDD.n39 0.189974
R744 VDD.n72 VDD.n56 0.0247608
R745 VDD.n18 VDD.n2 0.0247608
R746 VDD.n110 VDD.n0 0.020105
R747 VDD.n107 VDD.n55 0.00725
R748 VDD.n105 VDD.n55 0.00725
R749 VDD.n53 VDD.n1 0.00725
R750 VDD.n51 VDD.n1 0.00725
R751 VDD.n109 VDD.n108 0.0054955
R752 VDD.n109 VDD.n54 0.0054955
R753 VSS.n62 VSS.n61 5121.21
R754 VSS.n117 VSS.n62 5121.21
R755 VSS.n59 VSS.n58 4481.38
R756 VSS.n118 VSS.n117 4318.81
R757 VSS.n60 VSS.n59 3545.45
R758 VSS.n61 VSS.n60 3545.45
R759 VSS.t132 VSS.t124 1481.56
R760 VSS.t146 VSS.t144 1481.56
R761 VSS.t180 VSS.t140 1481.56
R762 VSS.t168 VSS.t22 1481.56
R763 VSS.t106 VSS.t42 1481.56
R764 VSS.t54 VSS.t34 1481.56
R765 VSS.t62 VSS.t60 1481.56
R766 VSS.t178 VSS.t74 1481.56
R767 VSS.t48 VSS.t160 1481.56
R768 VSS.t104 VSS.t76 1481.56
R769 VSS.t126 VSS.n4 1285.47
R770 VSS.n116 VSS.t36 1285.47
R771 VSS.n60 VSS.n3 933.913
R772 VSS.n61 VSS.n2 933.913
R773 VSS.n59 VSS.n4 907.822
R774 VSS.n117 VSS.n116 907.822
R775 VSS.n6 VSS.t50 481.769
R776 VSS.n112 VSS.t190 481.769
R777 VSS.n119 VSS.n62 351.675
R778 VSS.t128 VSS.t126 145.251
R779 VSS.t130 VSS.t128 145.251
R780 VSS.t124 VSS.t130 145.251
R781 VSS.t136 VSS.t132 145.251
R782 VSS.t138 VSS.t136 145.251
R783 VSS.t144 VSS.t138 145.251
R784 VSS.t134 VSS.t146 145.251
R785 VSS.t148 VSS.t134 145.251
R786 VSS.t150 VSS.t148 145.251
R787 VSS.t142 VSS.t150 145.251
R788 VSS.t152 VSS.t142 145.251
R789 VSS.t154 VSS.t152 145.251
R790 VSS.t140 VSS.t154 145.251
R791 VSS.t110 VSS.t180 145.251
R792 VSS.t108 VSS.t110 145.251
R793 VSS.t172 VSS.t108 145.251
R794 VSS.t170 VSS.t172 145.251
R795 VSS.t90 VSS.t170 145.251
R796 VSS.t88 VSS.t90 145.251
R797 VSS.t22 VSS.t88 145.251
R798 VSS.t166 VSS.t168 145.251
R799 VSS.t86 VSS.t166 145.251
R800 VSS.t84 VSS.t86 145.251
R801 VSS.t102 VSS.t84 145.251
R802 VSS.t100 VSS.t102 145.251
R803 VSS.t44 VSS.t100 145.251
R804 VSS.t42 VSS.t44 145.251
R805 VSS.t164 VSS.t106 145.251
R806 VSS.t162 VSS.t164 145.251
R807 VSS.t82 VSS.t162 145.251
R808 VSS.t80 VSS.t82 145.251
R809 VSS.t20 VSS.t80 145.251
R810 VSS.t18 VSS.t20 145.251
R811 VSS.t2 VSS.t18 145.251
R812 VSS.t0 VSS.t2 145.251
R813 VSS.t98 VSS.t0 145.251
R814 VSS.t96 VSS.t98 145.251
R815 VSS.t16 VSS.t96 145.251
R816 VSS.t14 VSS.t16 145.251
R817 VSS.t32 VSS.t14 145.251
R818 VSS.t30 VSS.t32 145.251
R819 VSS.t50 VSS.t30 145.251
R820 VSS.t38 VSS.t36 145.251
R821 VSS.t40 VSS.t38 145.251
R822 VSS.t34 VSS.t40 145.251
R823 VSS.t56 VSS.t54 145.251
R824 VSS.t58 VSS.t56 145.251
R825 VSS.t60 VSS.t58 145.251
R826 VSS.t52 VSS.t62 145.251
R827 VSS.t64 VSS.t52 145.251
R828 VSS.t66 VSS.t64 145.251
R829 VSS.t68 VSS.t66 145.251
R830 VSS.t70 VSS.t68 145.251
R831 VSS.t72 VSS.t70 145.251
R832 VSS.t74 VSS.t72 145.251
R833 VSS.t158 VSS.t178 145.251
R834 VSS.t156 VSS.t158 145.251
R835 VSS.t10 VSS.t156 145.251
R836 VSS.t8 VSS.t10 145.251
R837 VSS.t28 VSS.t8 145.251
R838 VSS.t12 VSS.t28 145.251
R839 VSS.t160 VSS.t12 145.251
R840 VSS.t46 VSS.t48 145.251
R841 VSS.t26 VSS.t46 145.251
R842 VSS.t24 VSS.t26 145.251
R843 VSS.t6 VSS.t24 145.251
R844 VSS.t4 VSS.t6 145.251
R845 VSS.t78 VSS.t4 145.251
R846 VSS.t76 VSS.t78 145.251
R847 VSS.t188 VSS.t104 145.251
R848 VSS.t186 VSS.t188 145.251
R849 VSS.t118 VSS.t186 145.251
R850 VSS.t116 VSS.t118 145.251
R851 VSS.t122 VSS.t116 145.251
R852 VSS.t120 VSS.t122 145.251
R853 VSS.t184 VSS.t120 145.251
R854 VSS.t182 VSS.t184 145.251
R855 VSS.t114 VSS.t182 145.251
R856 VSS.t112 VSS.t114 145.251
R857 VSS.t176 VSS.t112 145.251
R858 VSS.t174 VSS.t176 145.251
R859 VSS.t94 VSS.t174 145.251
R860 VSS.t92 VSS.t94 145.251
R861 VSS.t190 VSS.t92 145.251
R862 VSS.n5 VSS.n4 24.2219
R863 VSS.n116 VSS.n115 24.2219
R864 VSS.n22 VSS.n21 9.9768
R865 VSS.n30 VSS.n29 9.9768
R866 VSS.n38 VSS.n37 9.9768
R867 VSS.n46 VSS.n45 9.9768
R868 VSS.n50 VSS.n49 9.9768
R869 VSS.n54 VSS.n53 9.9768
R870 VSS.n111 VSS.n110 9.9768
R871 VSS.n95 VSS.n94 9.9768
R872 VSS.n87 VSS.n86 9.9768
R873 VSS.n79 VSS.n78 9.9768
R874 VSS.n71 VSS.n70 9.9768
R875 VSS.n67 VSS.n66 9.9768
R876 VSS.n9 VSS.n7 5.57485
R877 VSS.n25 VSS.n23 5.57485
R878 VSS.n33 VSS.n31 5.57485
R879 VSS.n41 VSS.n39 5.57485
R880 VSS.n49 VSS.n47 5.57485
R881 VSS.n53 VSS.n51 5.57485
R882 VSS.n98 VSS.n96 5.57485
R883 VSS.n90 VSS.n88 5.57485
R884 VSS.n82 VSS.n80 5.57485
R885 VSS.n74 VSS.n72 5.57485
R886 VSS.n70 VSS.n68 5.57485
R887 VSS.n66 VSS.n64 5.57485
R888 VSS.n21 VSS.n20 5.38537
R889 VSS.n19 VSS.n18 5.38537
R890 VSS.n17 VSS.n16 5.38537
R891 VSS.n15 VSS.n14 5.38537
R892 VSS.n13 VSS.n12 5.38537
R893 VSS.n11 VSS.n10 5.38537
R894 VSS.n9 VSS.n8 5.38537
R895 VSS.n29 VSS.n28 5.38537
R896 VSS.n27 VSS.n26 5.38537
R897 VSS.n25 VSS.n24 5.38537
R898 VSS.n37 VSS.n36 5.38537
R899 VSS.n35 VSS.n34 5.38537
R900 VSS.n33 VSS.n32 5.38537
R901 VSS.n45 VSS.n44 5.38537
R902 VSS.n43 VSS.n42 5.38537
R903 VSS.n41 VSS.n40 5.38537
R904 VSS.n49 VSS.n48 5.38537
R905 VSS.n53 VSS.n52 5.38537
R906 VSS.n110 VSS.n109 5.38537
R907 VSS.n108 VSS.n107 5.38537
R908 VSS.n106 VSS.n105 5.38537
R909 VSS.n104 VSS.n103 5.38537
R910 VSS.n102 VSS.n101 5.38537
R911 VSS.n100 VSS.n99 5.38537
R912 VSS.n98 VSS.n97 5.38537
R913 VSS.n94 VSS.n93 5.38537
R914 VSS.n92 VSS.n91 5.38537
R915 VSS.n90 VSS.n89 5.38537
R916 VSS.n86 VSS.n85 5.38537
R917 VSS.n84 VSS.n83 5.38537
R918 VSS.n82 VSS.n81 5.38537
R919 VSS.n78 VSS.n77 5.38537
R920 VSS.n76 VSS.n75 5.38537
R921 VSS.n74 VSS.n73 5.38537
R922 VSS.n70 VSS.n69 5.38537
R923 VSS.n66 VSS.n65 5.38537
R924 VSS.n1 VSS.n0 4.5005
R925 VSS.n120 VSS.n0 4.5005
R926 VSS.n122 VSS.n121 2.26839
R927 VSS.n57 VSS.n56 2.2545
R928 VSS.n113 VSS.n63 2.2545
R929 VSS.n56 VSS.n55 2.2505
R930 VSS.n114 VSS.n113 2.2505
R931 VSS.n58 VSS.n57 1.90124
R932 VSS.n118 VSS.n63 1.90124
R933 VSS.n56 VSS.n6 1.68318
R934 VSS.n113 VSS.n112 1.68318
R935 VSS VSS.n122 1.13544
R936 VSS.n58 VSS.n3 0.543479
R937 VSS.n3 VSS.n2 0.543479
R938 VSS.n119 VSS.n118 0.543479
R939 VSS.n2 VSS.n1 0.507615
R940 VSS.n120 VSS.n119 0.507363
R941 VSS.n30 VSS.n22 0.4541
R942 VSS.n111 VSS.n95 0.4541
R943 VSS.n50 VSS.n46 0.3101
R944 VSS.n46 VSS.n38 0.3101
R945 VSS.n38 VSS.n30 0.3101
R946 VSS.n79 VSS.n71 0.3101
R947 VSS.n87 VSS.n79 0.3101
R948 VSS.n95 VSS.n87 0.3101
R949 VSS.n54 VSS.n50 0.2381
R950 VSS.n71 VSS.n67 0.2381
R951 VSS.n55 VSS.n54 0.236975
R952 VSS.n114 VSS.n67 0.236975
R953 VSS.n20 VSS.t31 0.20525
R954 VSS.n20 VSS.t51 0.20525
R955 VSS.n18 VSS.t15 0.20525
R956 VSS.n18 VSS.t33 0.20525
R957 VSS.n16 VSS.t97 0.20525
R958 VSS.n16 VSS.t17 0.20525
R959 VSS.n14 VSS.t1 0.20525
R960 VSS.n14 VSS.t99 0.20525
R961 VSS.n12 VSS.t19 0.20525
R962 VSS.n12 VSS.t3 0.20525
R963 VSS.n10 VSS.t81 0.20525
R964 VSS.n10 VSS.t21 0.20525
R965 VSS.n8 VSS.t163 0.20525
R966 VSS.n8 VSS.t83 0.20525
R967 VSS.n7 VSS.t107 0.20525
R968 VSS.n7 VSS.t165 0.20525
R969 VSS.n28 VSS.t45 0.20525
R970 VSS.n28 VSS.t43 0.20525
R971 VSS.n26 VSS.t103 0.20525
R972 VSS.n26 VSS.t101 0.20525
R973 VSS.n24 VSS.t87 0.20525
R974 VSS.n24 VSS.t85 0.20525
R975 VSS.n23 VSS.t169 0.20525
R976 VSS.n23 VSS.t167 0.20525
R977 VSS.n36 VSS.t89 0.20525
R978 VSS.n36 VSS.t23 0.20525
R979 VSS.n34 VSS.t171 0.20525
R980 VSS.n34 VSS.t91 0.20525
R981 VSS.n32 VSS.t109 0.20525
R982 VSS.n32 VSS.t173 0.20525
R983 VSS.n31 VSS.t181 0.20525
R984 VSS.n31 VSS.t111 0.20525
R985 VSS.n44 VSS.t155 0.20525
R986 VSS.n44 VSS.t141 0.20525
R987 VSS.n42 VSS.t143 0.20525
R988 VSS.n42 VSS.t153 0.20525
R989 VSS.n40 VSS.t149 0.20525
R990 VSS.n40 VSS.t151 0.20525
R991 VSS.n39 VSS.t147 0.20525
R992 VSS.n39 VSS.t135 0.20525
R993 VSS.n48 VSS.t139 0.20525
R994 VSS.n48 VSS.t145 0.20525
R995 VSS.n47 VSS.t133 0.20525
R996 VSS.n47 VSS.t137 0.20525
R997 VSS.n52 VSS.t131 0.20525
R998 VSS.n52 VSS.t125 0.20525
R999 VSS.n51 VSS.t127 0.20525
R1000 VSS.n51 VSS.t129 0.20525
R1001 VSS.n109 VSS.t93 0.20525
R1002 VSS.n109 VSS.t191 0.20525
R1003 VSS.n107 VSS.t175 0.20525
R1004 VSS.n107 VSS.t95 0.20525
R1005 VSS.n105 VSS.t113 0.20525
R1006 VSS.n105 VSS.t177 0.20525
R1007 VSS.n103 VSS.t183 0.20525
R1008 VSS.n103 VSS.t115 0.20525
R1009 VSS.n101 VSS.t121 0.20525
R1010 VSS.n101 VSS.t185 0.20525
R1011 VSS.n99 VSS.t117 0.20525
R1012 VSS.n99 VSS.t123 0.20525
R1013 VSS.n97 VSS.t187 0.20525
R1014 VSS.n97 VSS.t119 0.20525
R1015 VSS.n96 VSS.t105 0.20525
R1016 VSS.n96 VSS.t189 0.20525
R1017 VSS.n93 VSS.t79 0.20525
R1018 VSS.n93 VSS.t77 0.20525
R1019 VSS.n91 VSS.t7 0.20525
R1020 VSS.n91 VSS.t5 0.20525
R1021 VSS.n89 VSS.t27 0.20525
R1022 VSS.n89 VSS.t25 0.20525
R1023 VSS.n88 VSS.t49 0.20525
R1024 VSS.n88 VSS.t47 0.20525
R1025 VSS.n85 VSS.t13 0.20525
R1026 VSS.n85 VSS.t161 0.20525
R1027 VSS.n83 VSS.t9 0.20525
R1028 VSS.n83 VSS.t29 0.20525
R1029 VSS.n81 VSS.t157 0.20525
R1030 VSS.n81 VSS.t11 0.20525
R1031 VSS.n80 VSS.t179 0.20525
R1032 VSS.n80 VSS.t159 0.20525
R1033 VSS.n77 VSS.t73 0.20525
R1034 VSS.n77 VSS.t75 0.20525
R1035 VSS.n75 VSS.t69 0.20525
R1036 VSS.n75 VSS.t71 0.20525
R1037 VSS.n73 VSS.t65 0.20525
R1038 VSS.n73 VSS.t67 0.20525
R1039 VSS.n72 VSS.t63 0.20525
R1040 VSS.n72 VSS.t53 0.20525
R1041 VSS.n69 VSS.t59 0.20525
R1042 VSS.n69 VSS.t61 0.20525
R1043 VSS.n68 VSS.t55 0.20525
R1044 VSS.n68 VSS.t57 0.20525
R1045 VSS.n65 VSS.t41 0.20525
R1046 VSS.n65 VSS.t35 0.20525
R1047 VSS.n64 VSS.t37 0.20525
R1048 VSS.n64 VSS.t39 0.20525
R1049 VSS.n11 VSS.n9 0.189974
R1050 VSS.n13 VSS.n11 0.189974
R1051 VSS.n15 VSS.n13 0.189974
R1052 VSS.n17 VSS.n15 0.189974
R1053 VSS.n19 VSS.n17 0.189974
R1054 VSS.n21 VSS.n19 0.189974
R1055 VSS.n27 VSS.n25 0.189974
R1056 VSS.n29 VSS.n27 0.189974
R1057 VSS.n35 VSS.n33 0.189974
R1058 VSS.n37 VSS.n35 0.189974
R1059 VSS.n43 VSS.n41 0.189974
R1060 VSS.n45 VSS.n43 0.189974
R1061 VSS.n100 VSS.n98 0.189974
R1062 VSS.n102 VSS.n100 0.189974
R1063 VSS.n104 VSS.n102 0.189974
R1064 VSS.n106 VSS.n104 0.189974
R1065 VSS.n108 VSS.n106 0.189974
R1066 VSS.n110 VSS.n108 0.189974
R1067 VSS.n92 VSS.n90 0.189974
R1068 VSS.n94 VSS.n92 0.189974
R1069 VSS.n84 VSS.n82 0.189974
R1070 VSS.n86 VSS.n84 0.189974
R1071 VSS.n76 VSS.n74 0.189974
R1072 VSS.n78 VSS.n76 0.189974
R1073 VSS.n22 VSS.n6 0.0247608
R1074 VSS.n112 VSS.n111 0.0247608
R1075 VSS.n122 VSS.n0 0.020105
R1076 VSS.n57 VSS.n5 0.00725
R1077 VSS.n55 VSS.n5 0.00725
R1078 VSS.n115 VSS.n63 0.00725
R1079 VSS.n115 VSS.n114 0.00725
R1080 VSS.n121 VSS.n120 0.0054955
R1081 VSS.n121 VSS.n1 0.0054955
R1082 a_6924_6400.n35 a_6924_6400.t31 113.632
R1083 a_6924_6400.n45 a_6924_6400.t16 113.632
R1084 a_6924_6400.n6 a_6924_6400.t47 113.632
R1085 a_6924_6400.n16 a_6924_6400.t32 113.632
R1086 a_6924_6400.n54 a_6924_6400.t23 109.174
R1087 a_6924_6400.n55 a_6924_6400.t24 109.174
R1088 a_6924_6400.n36 a_6924_6400.t30 109.174
R1089 a_6924_6400.n37 a_6924_6400.t29 109.174
R1090 a_6924_6400.n38 a_6924_6400.t28 109.174
R1091 a_6924_6400.n39 a_6924_6400.t27 109.174
R1092 a_6924_6400.n40 a_6924_6400.t26 109.174
R1093 a_6924_6400.n41 a_6924_6400.t25 109.174
R1094 a_6924_6400.n53 a_6924_6400.t22 109.174
R1095 a_6924_6400.n42 a_6924_6400.t21 109.174
R1096 a_6924_6400.n49 a_6924_6400.t20 109.174
R1097 a_6924_6400.n48 a_6924_6400.t19 109.174
R1098 a_6924_6400.n47 a_6924_6400.t18 109.174
R1099 a_6924_6400.n44 a_6924_6400.t17 109.174
R1100 a_6924_6400.n25 a_6924_6400.t39 109.174
R1101 a_6924_6400.n26 a_6924_6400.t40 109.174
R1102 a_6924_6400.n7 a_6924_6400.t46 109.174
R1103 a_6924_6400.n8 a_6924_6400.t45 109.174
R1104 a_6924_6400.n9 a_6924_6400.t44 109.174
R1105 a_6924_6400.n10 a_6924_6400.t43 109.174
R1106 a_6924_6400.n11 a_6924_6400.t42 109.174
R1107 a_6924_6400.n12 a_6924_6400.t41 109.174
R1108 a_6924_6400.n24 a_6924_6400.t38 109.174
R1109 a_6924_6400.n13 a_6924_6400.t37 109.174
R1110 a_6924_6400.n20 a_6924_6400.t36 109.174
R1111 a_6924_6400.n19 a_6924_6400.t35 109.174
R1112 a_6924_6400.n18 a_6924_6400.t34 109.174
R1113 a_6924_6400.n15 a_6924_6400.t33 109.174
R1114 a_6924_6400.n66 a_6924_6400.n58 19.9541
R1115 a_6924_6400.n54 a_6924_6400.n29 18.4942
R1116 a_6924_6400.n56 a_6924_6400.n55 18.4942
R1117 a_6924_6400.n37 a_6924_6400.n34 18.4942
R1118 a_6924_6400.n38 a_6924_6400.n33 18.4942
R1119 a_6924_6400.n39 a_6924_6400.n32 18.4942
R1120 a_6924_6400.n40 a_6924_6400.n31 18.4942
R1121 a_6924_6400.n41 a_6924_6400.n30 18.4942
R1122 a_6924_6400.n53 a_6924_6400.n52 18.4942
R1123 a_6924_6400.n51 a_6924_6400.n42 18.4942
R1124 a_6924_6400.n50 a_6924_6400.n49 18.4942
R1125 a_6924_6400.n48 a_6924_6400.n43 18.4942
R1126 a_6924_6400.n47 a_6924_6400.n46 18.4942
R1127 a_6924_6400.n25 a_6924_6400.n0 18.4942
R1128 a_6924_6400.n27 a_6924_6400.n26 18.4942
R1129 a_6924_6400.n8 a_6924_6400.n5 18.4942
R1130 a_6924_6400.n9 a_6924_6400.n4 18.4942
R1131 a_6924_6400.n10 a_6924_6400.n3 18.4942
R1132 a_6924_6400.n11 a_6924_6400.n2 18.4942
R1133 a_6924_6400.n12 a_6924_6400.n1 18.4942
R1134 a_6924_6400.n24 a_6924_6400.n23 18.4942
R1135 a_6924_6400.n22 a_6924_6400.n13 18.4942
R1136 a_6924_6400.n21 a_6924_6400.n20 18.4942
R1137 a_6924_6400.n19 a_6924_6400.n14 18.4942
R1138 a_6924_6400.n18 a_6924_6400.n17 18.4942
R1139 a_6924_6400.n54 a_6924_6400.n53 11.6805
R1140 a_6924_6400.n55 a_6924_6400.n54 11.6805
R1141 a_6924_6400.n37 a_6924_6400.n36 11.6805
R1142 a_6924_6400.n38 a_6924_6400.n37 11.6805
R1143 a_6924_6400.n39 a_6924_6400.n38 11.6805
R1144 a_6924_6400.n40 a_6924_6400.n39 11.6805
R1145 a_6924_6400.n41 a_6924_6400.n40 11.6805
R1146 a_6924_6400.n55 a_6924_6400.n41 11.6805
R1147 a_6924_6400.n53 a_6924_6400.n42 11.6805
R1148 a_6924_6400.n49 a_6924_6400.n42 11.6805
R1149 a_6924_6400.n49 a_6924_6400.n48 11.6805
R1150 a_6924_6400.n48 a_6924_6400.n47 11.6805
R1151 a_6924_6400.n47 a_6924_6400.n44 11.6805
R1152 a_6924_6400.n25 a_6924_6400.n24 11.6805
R1153 a_6924_6400.n26 a_6924_6400.n25 11.6805
R1154 a_6924_6400.n8 a_6924_6400.n7 11.6805
R1155 a_6924_6400.n9 a_6924_6400.n8 11.6805
R1156 a_6924_6400.n10 a_6924_6400.n9 11.6805
R1157 a_6924_6400.n11 a_6924_6400.n10 11.6805
R1158 a_6924_6400.n12 a_6924_6400.n11 11.6805
R1159 a_6924_6400.n26 a_6924_6400.n12 11.6805
R1160 a_6924_6400.n24 a_6924_6400.n13 11.6805
R1161 a_6924_6400.n20 a_6924_6400.n13 11.6805
R1162 a_6924_6400.n20 a_6924_6400.n19 11.6805
R1163 a_6924_6400.n19 a_6924_6400.n18 11.6805
R1164 a_6924_6400.n18 a_6924_6400.n15 11.6805
R1165 a_6924_6400.n58 a_6924_6400.n28 10.9291
R1166 a_6924_6400.n58 a_6924_6400.n57 9.0005
R1167 a_6924_6400.n46 a_6924_6400.n45 7.17687
R1168 a_6924_6400.n35 a_6924_6400.n34 7.17687
R1169 a_6924_6400.n17 a_6924_6400.n16 7.17687
R1170 a_6924_6400.n6 a_6924_6400.n5 7.17687
R1171 a_6924_6400.n67 a_6924_6400.n66 6.5392
R1172 a_6924_6400.n60 a_6924_6400.t15 5.7796
R1173 a_6924_6400.t7 a_6924_6400.n73 5.73764
R1174 a_6924_6400.n65 a_6924_6400.t8 5.59012
R1175 a_6924_6400.n67 a_6924_6400.t0 5.54817
R1176 a_6924_6400.n60 a_6924_6400.n59 5.38537
R1177 a_6924_6400.n62 a_6924_6400.n61 5.38537
R1178 a_6924_6400.n64 a_6924_6400.n63 5.38537
R1179 a_6924_6400.n73 a_6924_6400.n72 5.32067
R1180 a_6924_6400.n71 a_6924_6400.n70 5.32067
R1181 a_6924_6400.n69 a_6924_6400.n68 5.32067
R1182 a_6924_6400.n66 a_6924_6400.n65 4.61063
R1183 a_6924_6400.n36 a_6924_6400.n35 4.42851
R1184 a_6924_6400.n45 a_6924_6400.n44 4.42851
R1185 a_6924_6400.n7 a_6924_6400.n6 4.42851
R1186 a_6924_6400.n16 a_6924_6400.n15 4.42851
R1187 a_6924_6400.n72 a_6924_6400.t5 0.228
R1188 a_6924_6400.n72 a_6924_6400.t6 0.228
R1189 a_6924_6400.n70 a_6924_6400.t3 0.228
R1190 a_6924_6400.n70 a_6924_6400.t4 0.228
R1191 a_6924_6400.n68 a_6924_6400.t1 0.228
R1192 a_6924_6400.n68 a_6924_6400.t2 0.228
R1193 a_6924_6400.n59 a_6924_6400.t13 0.20525
R1194 a_6924_6400.n59 a_6924_6400.t14 0.20525
R1195 a_6924_6400.n61 a_6924_6400.t11 0.20525
R1196 a_6924_6400.n61 a_6924_6400.t12 0.20525
R1197 a_6924_6400.n63 a_6924_6400.t9 0.20525
R1198 a_6924_6400.n63 a_6924_6400.t10 0.20525
R1199 a_6924_6400.n69 a_6924_6400.n67 0.189974
R1200 a_6924_6400.n71 a_6924_6400.n69 0.189974
R1201 a_6924_6400.n73 a_6924_6400.n71 0.189974
R1202 a_6924_6400.n65 a_6924_6400.n64 0.189974
R1203 a_6924_6400.n64 a_6924_6400.n62 0.189974
R1204 a_6924_6400.n62 a_6924_6400.n60 0.189974
R1205 a_6924_6400.n52 a_6924_6400.n29 0.1205
R1206 a_6924_6400.n52 a_6924_6400.n51 0.1205
R1207 a_6924_6400.n51 a_6924_6400.n50 0.1205
R1208 a_6924_6400.n50 a_6924_6400.n43 0.1205
R1209 a_6924_6400.n46 a_6924_6400.n43 0.1205
R1210 a_6924_6400.n34 a_6924_6400.n33 0.1205
R1211 a_6924_6400.n33 a_6924_6400.n32 0.1205
R1212 a_6924_6400.n32 a_6924_6400.n31 0.1205
R1213 a_6924_6400.n31 a_6924_6400.n30 0.1205
R1214 a_6924_6400.n56 a_6924_6400.n30 0.1205
R1215 a_6924_6400.n23 a_6924_6400.n0 0.1205
R1216 a_6924_6400.n23 a_6924_6400.n22 0.1205
R1217 a_6924_6400.n22 a_6924_6400.n21 0.1205
R1218 a_6924_6400.n21 a_6924_6400.n14 0.1205
R1219 a_6924_6400.n17 a_6924_6400.n14 0.1205
R1220 a_6924_6400.n5 a_6924_6400.n4 0.1205
R1221 a_6924_6400.n4 a_6924_6400.n3 0.1205
R1222 a_6924_6400.n3 a_6924_6400.n2 0.1205
R1223 a_6924_6400.n2 a_6924_6400.n1 0.1205
R1224 a_6924_6400.n27 a_6924_6400.n1 0.1205
R1225 a_6924_6400.n57 a_6924_6400.n29 0.0485
R1226 a_6924_6400.n57 a_6924_6400.n56 0.0485
R1227 a_6924_6400.n28 a_6924_6400.n0 0.0485
R1228 a_6924_6400.n28 a_6924_6400.n27 0.0485
R1229 a_4812_6400.n15 a_4812_6400.t15 113.632
R1230 a_4812_6400.n19 a_4812_6400.t8 113.632
R1231 a_4812_6400.n2 a_4812_6400.t23 113.632
R1232 a_4812_6400.n6 a_4812_6400.t16 113.632
R1233 a_4812_6400.n22 a_4812_6400.t11 109.174
R1234 a_4812_6400.n23 a_4812_6400.t12 109.174
R1235 a_4812_6400.n16 a_4812_6400.t14 109.174
R1236 a_4812_6400.n17 a_4812_6400.t13 109.174
R1237 a_4812_6400.n21 a_4812_6400.t10 109.174
R1238 a_4812_6400.n18 a_4812_6400.t9 109.174
R1239 a_4812_6400.n9 a_4812_6400.t19 109.174
R1240 a_4812_6400.n10 a_4812_6400.t20 109.174
R1241 a_4812_6400.n3 a_4812_6400.t22 109.174
R1242 a_4812_6400.n4 a_4812_6400.t21 109.174
R1243 a_4812_6400.n8 a_4812_6400.t18 109.174
R1244 a_4812_6400.n5 a_4812_6400.t17 109.174
R1245 a_4812_6400.n22 a_4812_6400.n13 18.4942
R1246 a_4812_6400.n24 a_4812_6400.n23 18.4942
R1247 a_4812_6400.n17 a_4812_6400.n14 18.4942
R1248 a_4812_6400.n21 a_4812_6400.n20 18.4942
R1249 a_4812_6400.n9 a_4812_6400.n0 18.4942
R1250 a_4812_6400.n11 a_4812_6400.n10 18.4942
R1251 a_4812_6400.n4 a_4812_6400.n1 18.4942
R1252 a_4812_6400.n8 a_4812_6400.n7 18.4942
R1253 a_4812_6400.n30 a_4812_6400.n26 17.9305
R1254 a_4812_6400.n22 a_4812_6400.n21 11.6805
R1255 a_4812_6400.n23 a_4812_6400.n22 11.6805
R1256 a_4812_6400.n17 a_4812_6400.n16 11.6805
R1257 a_4812_6400.n23 a_4812_6400.n17 11.6805
R1258 a_4812_6400.n21 a_4812_6400.n18 11.6805
R1259 a_4812_6400.n9 a_4812_6400.n8 11.6805
R1260 a_4812_6400.n10 a_4812_6400.n9 11.6805
R1261 a_4812_6400.n4 a_4812_6400.n3 11.6805
R1262 a_4812_6400.n10 a_4812_6400.n4 11.6805
R1263 a_4812_6400.n8 a_4812_6400.n5 11.6805
R1264 a_4812_6400.n26 a_4812_6400.n12 10.3505
R1265 a_4812_6400.n26 a_4812_6400.n25 9.57907
R1266 a_4812_6400.n20 a_4812_6400.n19 7.17687
R1267 a_4812_6400.n15 a_4812_6400.n14 7.17687
R1268 a_4812_6400.n7 a_4812_6400.n6 7.17687
R1269 a_4812_6400.n2 a_4812_6400.n1 7.17687
R1270 a_4812_6400.n31 a_4812_6400.n30 6.5392
R1271 a_4812_6400.n28 a_4812_6400.t7 5.7796
R1272 a_4812_6400.t3 a_4812_6400.n33 5.73764
R1273 a_4812_6400.n29 a_4812_6400.t4 5.59012
R1274 a_4812_6400.n31 a_4812_6400.t0 5.54817
R1275 a_4812_6400.n28 a_4812_6400.n27 5.38537
R1276 a_4812_6400.n33 a_4812_6400.n32 5.32067
R1277 a_4812_6400.n30 a_4812_6400.n29 4.61063
R1278 a_4812_6400.n16 a_4812_6400.n15 4.42851
R1279 a_4812_6400.n19 a_4812_6400.n18 4.42851
R1280 a_4812_6400.n3 a_4812_6400.n2 4.42851
R1281 a_4812_6400.n6 a_4812_6400.n5 4.42851
R1282 a_4812_6400.n32 a_4812_6400.t1 0.228
R1283 a_4812_6400.n32 a_4812_6400.t2 0.228
R1284 a_4812_6400.n27 a_4812_6400.t5 0.20525
R1285 a_4812_6400.n27 a_4812_6400.t6 0.20525
R1286 a_4812_6400.n33 a_4812_6400.n31 0.189974
R1287 a_4812_6400.n29 a_4812_6400.n28 0.189974
R1288 a_4812_6400.n20 a_4812_6400.n13 0.1205
R1289 a_4812_6400.n24 a_4812_6400.n14 0.1205
R1290 a_4812_6400.n7 a_4812_6400.n0 0.1205
R1291 a_4812_6400.n11 a_4812_6400.n1 0.1205
R1292 a_4812_6400.n25 a_4812_6400.n13 0.0485
R1293 a_4812_6400.n25 a_4812_6400.n24 0.0485
R1294 a_4812_6400.n12 a_4812_6400.n0 0.0485
R1295 a_4812_6400.n12 a_4812_6400.n11 0.0485
R1296 a_2700_6400.n15 a_2700_6400.t15 113.632
R1297 a_2700_6400.n19 a_2700_6400.t8 113.632
R1298 a_2700_6400.n2 a_2700_6400.t23 113.632
R1299 a_2700_6400.n6 a_2700_6400.t16 113.632
R1300 a_2700_6400.n22 a_2700_6400.t11 109.174
R1301 a_2700_6400.n23 a_2700_6400.t12 109.174
R1302 a_2700_6400.n16 a_2700_6400.t14 109.174
R1303 a_2700_6400.n17 a_2700_6400.t13 109.174
R1304 a_2700_6400.n21 a_2700_6400.t10 109.174
R1305 a_2700_6400.n18 a_2700_6400.t9 109.174
R1306 a_2700_6400.n9 a_2700_6400.t19 109.174
R1307 a_2700_6400.n10 a_2700_6400.t20 109.174
R1308 a_2700_6400.n3 a_2700_6400.t22 109.174
R1309 a_2700_6400.n4 a_2700_6400.t21 109.174
R1310 a_2700_6400.n8 a_2700_6400.t18 109.174
R1311 a_2700_6400.n5 a_2700_6400.t17 109.174
R1312 a_2700_6400.n22 a_2700_6400.n13 18.4942
R1313 a_2700_6400.n24 a_2700_6400.n23 18.4942
R1314 a_2700_6400.n17 a_2700_6400.n14 18.4942
R1315 a_2700_6400.n21 a_2700_6400.n20 18.4942
R1316 a_2700_6400.n9 a_2700_6400.n0 18.4942
R1317 a_2700_6400.n11 a_2700_6400.n10 18.4942
R1318 a_2700_6400.n4 a_2700_6400.n1 18.4942
R1319 a_2700_6400.n8 a_2700_6400.n7 18.4942
R1320 a_2700_6400.n30 a_2700_6400.n26 17.6419
R1321 a_2700_6400.n22 a_2700_6400.n21 11.6805
R1322 a_2700_6400.n23 a_2700_6400.n22 11.6805
R1323 a_2700_6400.n17 a_2700_6400.n16 11.6805
R1324 a_2700_6400.n23 a_2700_6400.n17 11.6805
R1325 a_2700_6400.n21 a_2700_6400.n18 11.6805
R1326 a_2700_6400.n9 a_2700_6400.n8 11.6805
R1327 a_2700_6400.n10 a_2700_6400.n9 11.6805
R1328 a_2700_6400.n4 a_2700_6400.n3 11.6805
R1329 a_2700_6400.n10 a_2700_6400.n4 11.6805
R1330 a_2700_6400.n8 a_2700_6400.n5 11.6805
R1331 a_2700_6400.n26 a_2700_6400.n12 10.688
R1332 a_2700_6400.n26 a_2700_6400.n25 9.24157
R1333 a_2700_6400.n20 a_2700_6400.n19 7.17687
R1334 a_2700_6400.n15 a_2700_6400.n14 7.17687
R1335 a_2700_6400.n7 a_2700_6400.n6 7.17687
R1336 a_2700_6400.n2 a_2700_6400.n1 7.17687
R1337 a_2700_6400.n31 a_2700_6400.n30 6.5392
R1338 a_2700_6400.n28 a_2700_6400.t7 5.7796
R1339 a_2700_6400.t3 a_2700_6400.n33 5.73764
R1340 a_2700_6400.n29 a_2700_6400.t4 5.59012
R1341 a_2700_6400.n31 a_2700_6400.t0 5.54817
R1342 a_2700_6400.n28 a_2700_6400.n27 5.38537
R1343 a_2700_6400.n33 a_2700_6400.n32 5.32067
R1344 a_2700_6400.n30 a_2700_6400.n29 4.61063
R1345 a_2700_6400.n16 a_2700_6400.n15 4.42851
R1346 a_2700_6400.n19 a_2700_6400.n18 4.42851
R1347 a_2700_6400.n3 a_2700_6400.n2 4.42851
R1348 a_2700_6400.n6 a_2700_6400.n5 4.42851
R1349 a_2700_6400.n32 a_2700_6400.t1 0.228
R1350 a_2700_6400.n32 a_2700_6400.t2 0.228
R1351 a_2700_6400.n27 a_2700_6400.t5 0.20525
R1352 a_2700_6400.n27 a_2700_6400.t6 0.20525
R1353 a_2700_6400.n33 a_2700_6400.n31 0.189974
R1354 a_2700_6400.n29 a_2700_6400.n28 0.189974
R1355 a_2700_6400.n20 a_2700_6400.n13 0.1205
R1356 a_2700_6400.n24 a_2700_6400.n14 0.1205
R1357 a_2700_6400.n7 a_2700_6400.n0 0.1205
R1358 a_2700_6400.n11 a_2700_6400.n1 0.1205
R1359 a_2700_6400.n25 a_2700_6400.n13 0.0485
R1360 a_2700_6400.n25 a_2700_6400.n24 0.0485
R1361 a_2700_6400.n12 a_2700_6400.n0 0.0485
R1362 a_2700_6400.n12 a_2700_6400.n11 0.0485
R1363 a_6924_41600.n35 a_6924_41600.t31 113.632
R1364 a_6924_41600.n45 a_6924_41600.t16 113.632
R1365 a_6924_41600.n6 a_6924_41600.t47 113.632
R1366 a_6924_41600.n16 a_6924_41600.t32 113.632
R1367 a_6924_41600.n54 a_6924_41600.t23 109.174
R1368 a_6924_41600.n55 a_6924_41600.t24 109.174
R1369 a_6924_41600.n36 a_6924_41600.t30 109.174
R1370 a_6924_41600.n37 a_6924_41600.t29 109.174
R1371 a_6924_41600.n38 a_6924_41600.t28 109.174
R1372 a_6924_41600.n39 a_6924_41600.t27 109.174
R1373 a_6924_41600.n40 a_6924_41600.t26 109.174
R1374 a_6924_41600.n41 a_6924_41600.t25 109.174
R1375 a_6924_41600.n53 a_6924_41600.t22 109.174
R1376 a_6924_41600.n42 a_6924_41600.t21 109.174
R1377 a_6924_41600.n49 a_6924_41600.t20 109.174
R1378 a_6924_41600.n48 a_6924_41600.t19 109.174
R1379 a_6924_41600.n47 a_6924_41600.t18 109.174
R1380 a_6924_41600.n44 a_6924_41600.t17 109.174
R1381 a_6924_41600.n25 a_6924_41600.t39 109.174
R1382 a_6924_41600.n26 a_6924_41600.t40 109.174
R1383 a_6924_41600.n7 a_6924_41600.t46 109.174
R1384 a_6924_41600.n8 a_6924_41600.t45 109.174
R1385 a_6924_41600.n9 a_6924_41600.t44 109.174
R1386 a_6924_41600.n10 a_6924_41600.t43 109.174
R1387 a_6924_41600.n11 a_6924_41600.t42 109.174
R1388 a_6924_41600.n12 a_6924_41600.t41 109.174
R1389 a_6924_41600.n24 a_6924_41600.t38 109.174
R1390 a_6924_41600.n13 a_6924_41600.t37 109.174
R1391 a_6924_41600.n20 a_6924_41600.t36 109.174
R1392 a_6924_41600.n19 a_6924_41600.t35 109.174
R1393 a_6924_41600.n18 a_6924_41600.t34 109.174
R1394 a_6924_41600.n15 a_6924_41600.t33 109.174
R1395 a_6924_41600.n66 a_6924_41600.n58 19.9541
R1396 a_6924_41600.n54 a_6924_41600.n29 18.4942
R1397 a_6924_41600.n56 a_6924_41600.n55 18.4942
R1398 a_6924_41600.n37 a_6924_41600.n34 18.4942
R1399 a_6924_41600.n38 a_6924_41600.n33 18.4942
R1400 a_6924_41600.n39 a_6924_41600.n32 18.4942
R1401 a_6924_41600.n40 a_6924_41600.n31 18.4942
R1402 a_6924_41600.n41 a_6924_41600.n30 18.4942
R1403 a_6924_41600.n53 a_6924_41600.n52 18.4942
R1404 a_6924_41600.n51 a_6924_41600.n42 18.4942
R1405 a_6924_41600.n50 a_6924_41600.n49 18.4942
R1406 a_6924_41600.n48 a_6924_41600.n43 18.4942
R1407 a_6924_41600.n47 a_6924_41600.n46 18.4942
R1408 a_6924_41600.n25 a_6924_41600.n0 18.4942
R1409 a_6924_41600.n27 a_6924_41600.n26 18.4942
R1410 a_6924_41600.n8 a_6924_41600.n5 18.4942
R1411 a_6924_41600.n9 a_6924_41600.n4 18.4942
R1412 a_6924_41600.n10 a_6924_41600.n3 18.4942
R1413 a_6924_41600.n11 a_6924_41600.n2 18.4942
R1414 a_6924_41600.n12 a_6924_41600.n1 18.4942
R1415 a_6924_41600.n24 a_6924_41600.n23 18.4942
R1416 a_6924_41600.n22 a_6924_41600.n13 18.4942
R1417 a_6924_41600.n21 a_6924_41600.n20 18.4942
R1418 a_6924_41600.n19 a_6924_41600.n14 18.4942
R1419 a_6924_41600.n18 a_6924_41600.n17 18.4942
R1420 a_6924_41600.n54 a_6924_41600.n53 11.6805
R1421 a_6924_41600.n55 a_6924_41600.n54 11.6805
R1422 a_6924_41600.n37 a_6924_41600.n36 11.6805
R1423 a_6924_41600.n38 a_6924_41600.n37 11.6805
R1424 a_6924_41600.n39 a_6924_41600.n38 11.6805
R1425 a_6924_41600.n40 a_6924_41600.n39 11.6805
R1426 a_6924_41600.n41 a_6924_41600.n40 11.6805
R1427 a_6924_41600.n55 a_6924_41600.n41 11.6805
R1428 a_6924_41600.n53 a_6924_41600.n42 11.6805
R1429 a_6924_41600.n49 a_6924_41600.n42 11.6805
R1430 a_6924_41600.n49 a_6924_41600.n48 11.6805
R1431 a_6924_41600.n48 a_6924_41600.n47 11.6805
R1432 a_6924_41600.n47 a_6924_41600.n44 11.6805
R1433 a_6924_41600.n25 a_6924_41600.n24 11.6805
R1434 a_6924_41600.n26 a_6924_41600.n25 11.6805
R1435 a_6924_41600.n8 a_6924_41600.n7 11.6805
R1436 a_6924_41600.n9 a_6924_41600.n8 11.6805
R1437 a_6924_41600.n10 a_6924_41600.n9 11.6805
R1438 a_6924_41600.n11 a_6924_41600.n10 11.6805
R1439 a_6924_41600.n12 a_6924_41600.n11 11.6805
R1440 a_6924_41600.n26 a_6924_41600.n12 11.6805
R1441 a_6924_41600.n24 a_6924_41600.n13 11.6805
R1442 a_6924_41600.n20 a_6924_41600.n13 11.6805
R1443 a_6924_41600.n20 a_6924_41600.n19 11.6805
R1444 a_6924_41600.n19 a_6924_41600.n18 11.6805
R1445 a_6924_41600.n18 a_6924_41600.n15 11.6805
R1446 a_6924_41600.n58 a_6924_41600.n28 10.9291
R1447 a_6924_41600.n58 a_6924_41600.n57 9.0005
R1448 a_6924_41600.n46 a_6924_41600.n45 7.17687
R1449 a_6924_41600.n35 a_6924_41600.n34 7.17687
R1450 a_6924_41600.n17 a_6924_41600.n16 7.17687
R1451 a_6924_41600.n6 a_6924_41600.n5 7.17687
R1452 a_6924_41600.n67 a_6924_41600.n66 6.5392
R1453 a_6924_41600.n60 a_6924_41600.t15 5.7796
R1454 a_6924_41600.t7 a_6924_41600.n73 5.73764
R1455 a_6924_41600.n65 a_6924_41600.t8 5.59012
R1456 a_6924_41600.n67 a_6924_41600.t0 5.54817
R1457 a_6924_41600.n60 a_6924_41600.n59 5.38537
R1458 a_6924_41600.n62 a_6924_41600.n61 5.38537
R1459 a_6924_41600.n64 a_6924_41600.n63 5.38537
R1460 a_6924_41600.n73 a_6924_41600.n72 5.32067
R1461 a_6924_41600.n71 a_6924_41600.n70 5.32067
R1462 a_6924_41600.n69 a_6924_41600.n68 5.32067
R1463 a_6924_41600.n66 a_6924_41600.n65 4.61063
R1464 a_6924_41600.n36 a_6924_41600.n35 4.42851
R1465 a_6924_41600.n45 a_6924_41600.n44 4.42851
R1466 a_6924_41600.n7 a_6924_41600.n6 4.42851
R1467 a_6924_41600.n16 a_6924_41600.n15 4.42851
R1468 a_6924_41600.n72 a_6924_41600.t5 0.228
R1469 a_6924_41600.n72 a_6924_41600.t6 0.228
R1470 a_6924_41600.n70 a_6924_41600.t3 0.228
R1471 a_6924_41600.n70 a_6924_41600.t4 0.228
R1472 a_6924_41600.n68 a_6924_41600.t1 0.228
R1473 a_6924_41600.n68 a_6924_41600.t2 0.228
R1474 a_6924_41600.n59 a_6924_41600.t13 0.20525
R1475 a_6924_41600.n59 a_6924_41600.t14 0.20525
R1476 a_6924_41600.n61 a_6924_41600.t11 0.20525
R1477 a_6924_41600.n61 a_6924_41600.t12 0.20525
R1478 a_6924_41600.n63 a_6924_41600.t9 0.20525
R1479 a_6924_41600.n63 a_6924_41600.t10 0.20525
R1480 a_6924_41600.n69 a_6924_41600.n67 0.189974
R1481 a_6924_41600.n71 a_6924_41600.n69 0.189974
R1482 a_6924_41600.n73 a_6924_41600.n71 0.189974
R1483 a_6924_41600.n65 a_6924_41600.n64 0.189974
R1484 a_6924_41600.n64 a_6924_41600.n62 0.189974
R1485 a_6924_41600.n62 a_6924_41600.n60 0.189974
R1486 a_6924_41600.n52 a_6924_41600.n29 0.1205
R1487 a_6924_41600.n52 a_6924_41600.n51 0.1205
R1488 a_6924_41600.n51 a_6924_41600.n50 0.1205
R1489 a_6924_41600.n50 a_6924_41600.n43 0.1205
R1490 a_6924_41600.n46 a_6924_41600.n43 0.1205
R1491 a_6924_41600.n34 a_6924_41600.n33 0.1205
R1492 a_6924_41600.n33 a_6924_41600.n32 0.1205
R1493 a_6924_41600.n32 a_6924_41600.n31 0.1205
R1494 a_6924_41600.n31 a_6924_41600.n30 0.1205
R1495 a_6924_41600.n56 a_6924_41600.n30 0.1205
R1496 a_6924_41600.n23 a_6924_41600.n0 0.1205
R1497 a_6924_41600.n23 a_6924_41600.n22 0.1205
R1498 a_6924_41600.n22 a_6924_41600.n21 0.1205
R1499 a_6924_41600.n21 a_6924_41600.n14 0.1205
R1500 a_6924_41600.n17 a_6924_41600.n14 0.1205
R1501 a_6924_41600.n5 a_6924_41600.n4 0.1205
R1502 a_6924_41600.n4 a_6924_41600.n3 0.1205
R1503 a_6924_41600.n3 a_6924_41600.n2 0.1205
R1504 a_6924_41600.n2 a_6924_41600.n1 0.1205
R1505 a_6924_41600.n27 a_6924_41600.n1 0.1205
R1506 a_6924_41600.n57 a_6924_41600.n29 0.0485
R1507 a_6924_41600.n57 a_6924_41600.n56 0.0485
R1508 a_6924_41600.n28 a_6924_41600.n0 0.0485
R1509 a_6924_41600.n28 a_6924_41600.n27 0.0485
R1510 a_4812_41600.n15 a_4812_41600.t15 113.632
R1511 a_4812_41600.n19 a_4812_41600.t8 113.632
R1512 a_4812_41600.n2 a_4812_41600.t23 113.632
R1513 a_4812_41600.n6 a_4812_41600.t16 113.632
R1514 a_4812_41600.n22 a_4812_41600.t11 109.174
R1515 a_4812_41600.n23 a_4812_41600.t12 109.174
R1516 a_4812_41600.n16 a_4812_41600.t14 109.174
R1517 a_4812_41600.n17 a_4812_41600.t13 109.174
R1518 a_4812_41600.n21 a_4812_41600.t10 109.174
R1519 a_4812_41600.n18 a_4812_41600.t9 109.174
R1520 a_4812_41600.n9 a_4812_41600.t19 109.174
R1521 a_4812_41600.n10 a_4812_41600.t20 109.174
R1522 a_4812_41600.n3 a_4812_41600.t22 109.174
R1523 a_4812_41600.n4 a_4812_41600.t21 109.174
R1524 a_4812_41600.n8 a_4812_41600.t18 109.174
R1525 a_4812_41600.n5 a_4812_41600.t17 109.174
R1526 a_4812_41600.n22 a_4812_41600.n13 18.4942
R1527 a_4812_41600.n24 a_4812_41600.n23 18.4942
R1528 a_4812_41600.n17 a_4812_41600.n14 18.4942
R1529 a_4812_41600.n21 a_4812_41600.n20 18.4942
R1530 a_4812_41600.n9 a_4812_41600.n0 18.4942
R1531 a_4812_41600.n11 a_4812_41600.n10 18.4942
R1532 a_4812_41600.n4 a_4812_41600.n1 18.4942
R1533 a_4812_41600.n8 a_4812_41600.n7 18.4942
R1534 a_4812_41600.n30 a_4812_41600.n26 17.9305
R1535 a_4812_41600.n22 a_4812_41600.n21 11.6805
R1536 a_4812_41600.n23 a_4812_41600.n22 11.6805
R1537 a_4812_41600.n17 a_4812_41600.n16 11.6805
R1538 a_4812_41600.n23 a_4812_41600.n17 11.6805
R1539 a_4812_41600.n21 a_4812_41600.n18 11.6805
R1540 a_4812_41600.n9 a_4812_41600.n8 11.6805
R1541 a_4812_41600.n10 a_4812_41600.n9 11.6805
R1542 a_4812_41600.n4 a_4812_41600.n3 11.6805
R1543 a_4812_41600.n10 a_4812_41600.n4 11.6805
R1544 a_4812_41600.n8 a_4812_41600.n5 11.6805
R1545 a_4812_41600.n26 a_4812_41600.n12 10.3505
R1546 a_4812_41600.n26 a_4812_41600.n25 9.57907
R1547 a_4812_41600.n20 a_4812_41600.n19 7.17687
R1548 a_4812_41600.n15 a_4812_41600.n14 7.17687
R1549 a_4812_41600.n7 a_4812_41600.n6 7.17687
R1550 a_4812_41600.n2 a_4812_41600.n1 7.17687
R1551 a_4812_41600.n31 a_4812_41600.n30 6.5392
R1552 a_4812_41600.n28 a_4812_41600.t7 5.7796
R1553 a_4812_41600.t3 a_4812_41600.n33 5.73764
R1554 a_4812_41600.n29 a_4812_41600.t4 5.59012
R1555 a_4812_41600.n31 a_4812_41600.t0 5.54817
R1556 a_4812_41600.n28 a_4812_41600.n27 5.38537
R1557 a_4812_41600.n33 a_4812_41600.n32 5.32067
R1558 a_4812_41600.n30 a_4812_41600.n29 4.61063
R1559 a_4812_41600.n16 a_4812_41600.n15 4.42851
R1560 a_4812_41600.n19 a_4812_41600.n18 4.42851
R1561 a_4812_41600.n3 a_4812_41600.n2 4.42851
R1562 a_4812_41600.n6 a_4812_41600.n5 4.42851
R1563 a_4812_41600.n32 a_4812_41600.t1 0.228
R1564 a_4812_41600.n32 a_4812_41600.t2 0.228
R1565 a_4812_41600.n27 a_4812_41600.t5 0.20525
R1566 a_4812_41600.n27 a_4812_41600.t6 0.20525
R1567 a_4812_41600.n33 a_4812_41600.n31 0.189974
R1568 a_4812_41600.n29 a_4812_41600.n28 0.189974
R1569 a_4812_41600.n20 a_4812_41600.n13 0.1205
R1570 a_4812_41600.n24 a_4812_41600.n14 0.1205
R1571 a_4812_41600.n7 a_4812_41600.n0 0.1205
R1572 a_4812_41600.n11 a_4812_41600.n1 0.1205
R1573 a_4812_41600.n25 a_4812_41600.n13 0.0485
R1574 a_4812_41600.n25 a_4812_41600.n24 0.0485
R1575 a_4812_41600.n12 a_4812_41600.n0 0.0485
R1576 a_4812_41600.n12 a_4812_41600.n11 0.0485
R1577 a_2700_41600.n15 a_2700_41600.t15 113.632
R1578 a_2700_41600.n19 a_2700_41600.t8 113.632
R1579 a_2700_41600.n2 a_2700_41600.t23 113.632
R1580 a_2700_41600.n6 a_2700_41600.t16 113.632
R1581 a_2700_41600.n22 a_2700_41600.t11 109.174
R1582 a_2700_41600.n23 a_2700_41600.t12 109.174
R1583 a_2700_41600.n16 a_2700_41600.t14 109.174
R1584 a_2700_41600.n17 a_2700_41600.t13 109.174
R1585 a_2700_41600.n21 a_2700_41600.t10 109.174
R1586 a_2700_41600.n18 a_2700_41600.t9 109.174
R1587 a_2700_41600.n9 a_2700_41600.t19 109.174
R1588 a_2700_41600.n10 a_2700_41600.t20 109.174
R1589 a_2700_41600.n3 a_2700_41600.t22 109.174
R1590 a_2700_41600.n4 a_2700_41600.t21 109.174
R1591 a_2700_41600.n8 a_2700_41600.t18 109.174
R1592 a_2700_41600.n5 a_2700_41600.t17 109.174
R1593 a_2700_41600.n22 a_2700_41600.n13 18.4942
R1594 a_2700_41600.n24 a_2700_41600.n23 18.4942
R1595 a_2700_41600.n17 a_2700_41600.n14 18.4942
R1596 a_2700_41600.n21 a_2700_41600.n20 18.4942
R1597 a_2700_41600.n9 a_2700_41600.n0 18.4942
R1598 a_2700_41600.n11 a_2700_41600.n10 18.4942
R1599 a_2700_41600.n4 a_2700_41600.n1 18.4942
R1600 a_2700_41600.n8 a_2700_41600.n7 18.4942
R1601 a_2700_41600.n30 a_2700_41600.n26 17.6419
R1602 a_2700_41600.n22 a_2700_41600.n21 11.6805
R1603 a_2700_41600.n23 a_2700_41600.n22 11.6805
R1604 a_2700_41600.n17 a_2700_41600.n16 11.6805
R1605 a_2700_41600.n23 a_2700_41600.n17 11.6805
R1606 a_2700_41600.n21 a_2700_41600.n18 11.6805
R1607 a_2700_41600.n9 a_2700_41600.n8 11.6805
R1608 a_2700_41600.n10 a_2700_41600.n9 11.6805
R1609 a_2700_41600.n4 a_2700_41600.n3 11.6805
R1610 a_2700_41600.n10 a_2700_41600.n4 11.6805
R1611 a_2700_41600.n8 a_2700_41600.n5 11.6805
R1612 a_2700_41600.n26 a_2700_41600.n12 10.688
R1613 a_2700_41600.n26 a_2700_41600.n25 9.24157
R1614 a_2700_41600.n20 a_2700_41600.n19 7.17687
R1615 a_2700_41600.n15 a_2700_41600.n14 7.17687
R1616 a_2700_41600.n7 a_2700_41600.n6 7.17687
R1617 a_2700_41600.n2 a_2700_41600.n1 7.17687
R1618 a_2700_41600.n31 a_2700_41600.n30 6.5392
R1619 a_2700_41600.n28 a_2700_41600.t7 5.7796
R1620 a_2700_41600.t3 a_2700_41600.n33 5.73764
R1621 a_2700_41600.n29 a_2700_41600.t4 5.59012
R1622 a_2700_41600.n31 a_2700_41600.t0 5.54817
R1623 a_2700_41600.n28 a_2700_41600.n27 5.38537
R1624 a_2700_41600.n33 a_2700_41600.n32 5.32067
R1625 a_2700_41600.n30 a_2700_41600.n29 4.61063
R1626 a_2700_41600.n16 a_2700_41600.n15 4.42851
R1627 a_2700_41600.n19 a_2700_41600.n18 4.42851
R1628 a_2700_41600.n3 a_2700_41600.n2 4.42851
R1629 a_2700_41600.n6 a_2700_41600.n5 4.42851
R1630 a_2700_41600.n32 a_2700_41600.t1 0.228
R1631 a_2700_41600.n32 a_2700_41600.t2 0.228
R1632 a_2700_41600.n27 a_2700_41600.t5 0.20525
R1633 a_2700_41600.n27 a_2700_41600.t6 0.20525
R1634 a_2700_41600.n33 a_2700_41600.n31 0.189974
R1635 a_2700_41600.n29 a_2700_41600.n28 0.189974
R1636 a_2700_41600.n20 a_2700_41600.n13 0.1205
R1637 a_2700_41600.n24 a_2700_41600.n14 0.1205
R1638 a_2700_41600.n7 a_2700_41600.n0 0.1205
R1639 a_2700_41600.n11 a_2700_41600.n1 0.1205
R1640 a_2700_41600.n25 a_2700_41600.n13 0.0485
R1641 a_2700_41600.n25 a_2700_41600.n24 0.0485
R1642 a_2700_41600.n12 a_2700_41600.n0 0.0485
R1643 a_2700_41600.n12 a_2700_41600.n11 0.0485
C0 E_CAPTURE_CLKB E_CAPTURE_CLK 0.1173f
C1 VDD CLKN_HB 1.54483f
C2 O_CAPTURE_CLK O_CAPTURE_CLKB 0.1173f
C3 E_SENSE E_CAPTURE_CLK 0.13944f
C4 CLKP_HB VDD 1.54483f
C5 O_CAPTURE_CLK O_SENSE 0.13944f
C6 CLKN_HB CLKN_H 0.01686f
C7 VDD E_CAPTURE_CLKB 11.2784f
C8 VDD O_CAPTURE_CLKB 11.2784f
C9 VDD E_CAPTURE_CLK 11.3088f
C10 CLKP_HB CLKP_H 0.01686f
C11 CLKP_H VDD 7.3037f
C12 VDD CLKN_H 7.3037f
C13 VDD E_SENSE 21.1051f
C14 VDD O_SENSE 21.1051f
C15 VDD O_CAPTURE_CLK 11.3088f
C16 E_SENSE VSS 22.83079f
C17 E_CAPTURE_CLK VSS 11.6014f
C18 E_CAPTURE_CLKB VSS 11.68514f
C19 CLKP_H VSS 17.452f
C20 CLKP_HB VSS 5.56653f
C21 O_SENSE VSS 22.83079f
C22 O_CAPTURE_CLK VSS 11.6014f
C23 O_CAPTURE_CLKB VSS 11.68514f
C24 CLKN_H VSS 17.452f
C25 CLKN_HB VSS 6.03473f
C26 VDD VSS 1.97025p
C27 a_2700_41600.n0 VSS 0.05379f
C28 a_2700_41600.n1 VSS 0.18581f
C29 a_2700_41600.n2 VSS 0.09184f
C30 a_2700_41600.n3 VSS 0.09845f
C31 a_2700_41600.n4 VSS 0.09845f
C32 a_2700_41600.n5 VSS 0.09845f
C33 a_2700_41600.n6 VSS 0.09184f
C34 a_2700_41600.n7 VSS 0.18581f
C35 a_2700_41600.n8 VSS 0.09845f
C36 a_2700_41600.n9 VSS 0.09845f
C37 a_2700_41600.n10 VSS 0.09845f
C38 a_2700_41600.n11 VSS 0.05379f
C39 a_2700_41600.n12 VSS 0.30195f
C40 a_2700_41600.n13 VSS 0.05379f
C41 a_2700_41600.n14 VSS 0.18581f
C42 a_2700_41600.n15 VSS 0.09184f
C43 a_2700_41600.n16 VSS 0.09845f
C44 a_2700_41600.n17 VSS 0.09845f
C45 a_2700_41600.n18 VSS 0.09845f
C46 a_2700_41600.n19 VSS 0.09184f
C47 a_2700_41600.n20 VSS 0.18581f
C48 a_2700_41600.n21 VSS 0.09845f
C49 a_2700_41600.n22 VSS 0.09845f
C50 a_2700_41600.n23 VSS 0.09845f
C51 a_2700_41600.n24 VSS 0.05379f
C52 a_2700_41600.n25 VSS 0.22616f
C53 a_2700_41600.n26 VSS 2.10925f
C54 a_2700_41600.t7 VSS 0.77855f
C55 a_2700_41600.t6 VSS 0.17409f
C56 a_2700_41600.t5 VSS 0.17409f
C57 a_2700_41600.n27 VSS 0.57755f
C58 a_2700_41600.n28 VSS 0.3255f
C59 a_2700_41600.t4 VSS 0.77332f
C60 a_2700_41600.n29 VSS 0.23422f
C61 a_2700_41600.n30 VSS 1.96271f
C62 a_2700_41600.t0 VSS 0.77472f
C63 a_2700_41600.n31 VSS 0.34542f
C64 a_2700_41600.t2 VSS 0.17409f
C65 a_2700_41600.t1 VSS 0.17409f
C66 a_2700_41600.n32 VSS 0.58184f
C67 a_2700_41600.n33 VSS 0.31982f
C68 a_2700_41600.t3 VSS 0.77994f
C69 a_4812_41600.n0 VSS 0.05444f
C70 a_4812_41600.n1 VSS 0.18807f
C71 a_4812_41600.n2 VSS 0.09296f
C72 a_4812_41600.n3 VSS 0.09965f
C73 a_4812_41600.n4 VSS 0.09965f
C74 a_4812_41600.n5 VSS 0.09965f
C75 a_4812_41600.n6 VSS 0.09296f
C76 a_4812_41600.n7 VSS 0.18807f
C77 a_4812_41600.n8 VSS 0.09965f
C78 a_4812_41600.n9 VSS 0.09965f
C79 a_4812_41600.n10 VSS 0.09965f
C80 a_4812_41600.n11 VSS 0.05444f
C81 a_4812_41600.n12 VSS 0.28276f
C82 a_4812_41600.n13 VSS 0.05444f
C83 a_4812_41600.n14 VSS 0.18807f
C84 a_4812_41600.n15 VSS 0.09296f
C85 a_4812_41600.n16 VSS 0.09965f
C86 a_4812_41600.n17 VSS 0.09965f
C87 a_4812_41600.n18 VSS 0.09965f
C88 a_4812_41600.n19 VSS 0.09296f
C89 a_4812_41600.n20 VSS 0.18807f
C90 a_4812_41600.n21 VSS 0.09965f
C91 a_4812_41600.n22 VSS 0.09965f
C92 a_4812_41600.n23 VSS 0.09965f
C93 a_4812_41600.n24 VSS 0.05444f
C94 a_4812_41600.n25 VSS 0.24144f
C95 a_4812_41600.n26 VSS 2.20235f
C96 a_4812_41600.t7 VSS 0.79057f
C97 a_4812_41600.t6 VSS 0.17869f
C98 a_4812_41600.t5 VSS 0.17869f
C99 a_4812_41600.n27 VSS 0.58459f
C100 a_4812_41600.n28 VSS 0.32947f
C101 a_4812_41600.t4 VSS 0.78527f
C102 a_4812_41600.n29 VSS 0.23707f
C103 a_4812_41600.n30 VSS 1.962f
C104 a_4812_41600.t0 VSS 0.78669f
C105 a_4812_41600.n31 VSS 0.34963f
C106 a_4812_41600.t2 VSS 0.17869f
C107 a_4812_41600.t1 VSS 0.17869f
C108 a_4812_41600.n32 VSS 0.58894f
C109 a_4812_41600.n33 VSS 0.32372f
C110 a_4812_41600.t3 VSS 0.79197f
C111 a_6924_41600.n0 VSS 0.05256f
C112 a_6924_41600.n1 VSS 0.06238f
C113 a_6924_41600.n2 VSS 0.06238f
C114 a_6924_41600.n3 VSS 0.06238f
C115 a_6924_41600.n4 VSS 0.06238f
C116 a_6924_41600.n5 VSS 0.18155f
C117 a_6924_41600.n6 VSS 0.08974f
C118 a_6924_41600.n7 VSS 0.09619f
C119 a_6924_41600.n8 VSS 0.09619f
C120 a_6924_41600.n9 VSS 0.09619f
C121 a_6924_41600.n10 VSS 0.09619f
C122 a_6924_41600.n11 VSS 0.09619f
C123 a_6924_41600.n12 VSS 0.09619f
C124 a_6924_41600.n13 VSS 0.09619f
C125 a_6924_41600.n14 VSS 0.06238f
C126 a_6924_41600.n15 VSS 0.09619f
C127 a_6924_41600.n16 VSS 0.08974f
C128 a_6924_41600.n17 VSS 0.18155f
C129 a_6924_41600.n18 VSS 0.09619f
C130 a_6924_41600.n19 VSS 0.09619f
C131 a_6924_41600.n20 VSS 0.09619f
C132 a_6924_41600.n21 VSS 0.06238f
C133 a_6924_41600.n22 VSS 0.06238f
C134 a_6924_41600.n23 VSS 0.06238f
C135 a_6924_41600.n24 VSS 0.09619f
C136 a_6924_41600.n25 VSS 0.09619f
C137 a_6924_41600.n26 VSS 0.09619f
C138 a_6924_41600.n27 VSS 0.05256f
C139 a_6924_41600.n28 VSS 0.53497f
C140 a_6924_41600.n29 VSS 0.05256f
C141 a_6924_41600.n30 VSS 0.06238f
C142 a_6924_41600.n31 VSS 0.06238f
C143 a_6924_41600.n32 VSS 0.06238f
C144 a_6924_41600.n33 VSS 0.06238f
C145 a_6924_41600.n34 VSS 0.18155f
C146 a_6924_41600.n35 VSS 0.08974f
C147 a_6924_41600.n36 VSS 0.09619f
C148 a_6924_41600.n37 VSS 0.09619f
C149 a_6924_41600.n38 VSS 0.09619f
C150 a_6924_41600.n39 VSS 0.09619f
C151 a_6924_41600.n40 VSS 0.09619f
C152 a_6924_41600.n41 VSS 0.09619f
C153 a_6924_41600.n42 VSS 0.09619f
C154 a_6924_41600.n43 VSS 0.06238f
C155 a_6924_41600.n44 VSS 0.09619f
C156 a_6924_41600.n45 VSS 0.08974f
C157 a_6924_41600.n46 VSS 0.18155f
C158 a_6924_41600.n47 VSS 0.09619f
C159 a_6924_41600.n48 VSS 0.09619f
C160 a_6924_41600.n49 VSS 0.09619f
C161 a_6924_41600.n50 VSS 0.06238f
C162 a_6924_41600.n51 VSS 0.06238f
C163 a_6924_41600.n52 VSS 0.06238f
C164 a_6924_41600.n53 VSS 0.09619f
C165 a_6924_41600.n54 VSS 0.09619f
C166 a_6924_41600.n55 VSS 0.09619f
C167 a_6924_41600.n56 VSS 0.05256f
C168 a_6924_41600.n57 VSS 0.40388f
C169 a_6924_41600.n58 VSS 2.68995f
C170 a_6924_41600.t15 VSS 0.76545f
C171 a_6924_41600.t14 VSS 0.17474f
C172 a_6924_41600.t13 VSS 0.17474f
C173 a_6924_41600.n59 VSS 0.56432f
C174 a_6924_41600.n60 VSS 0.31804f
C175 a_6924_41600.t12 VSS 0.17474f
C176 a_6924_41600.t11 VSS 0.17474f
C177 a_6924_41600.n61 VSS 0.56432f
C178 a_6924_41600.n62 VSS 0.16732f
C179 a_6924_41600.t10 VSS 0.17474f
C180 a_6924_41600.t9 VSS 0.17474f
C181 a_6924_41600.n63 VSS 0.56432f
C182 a_6924_41600.n64 VSS 0.16732f
C183 a_6924_41600.t8 VSS 0.76034f
C184 a_6924_41600.n65 VSS 0.22885f
C185 a_6924_41600.n66 VSS 2.24895f
C186 a_6924_41600.t0 VSS 0.7617f
C187 a_6924_41600.n67 VSS 0.33751f
C188 a_6924_41600.t2 VSS 0.17474f
C189 a_6924_41600.t1 VSS 0.17474f
C190 a_6924_41600.n68 VSS 0.56852f
C191 a_6924_41600.n69 VSS 0.16313f
C192 a_6924_41600.t4 VSS 0.17474f
C193 a_6924_41600.t3 VSS 0.17474f
C194 a_6924_41600.n70 VSS 0.56852f
C195 a_6924_41600.n71 VSS 0.16313f
C196 a_6924_41600.t6 VSS 0.17474f
C197 a_6924_41600.t5 VSS 0.17474f
C198 a_6924_41600.n72 VSS 0.56852f
C199 a_6924_41600.n73 VSS 0.31249f
C200 a_6924_41600.t7 VSS 0.7668f
C201 a_2700_6400.n0 VSS 0.05379f
C202 a_2700_6400.n1 VSS 0.18581f
C203 a_2700_6400.n2 VSS 0.09184f
C204 a_2700_6400.n3 VSS 0.09845f
C205 a_2700_6400.n4 VSS 0.09845f
C206 a_2700_6400.n5 VSS 0.09845f
C207 a_2700_6400.n6 VSS 0.09184f
C208 a_2700_6400.n7 VSS 0.18581f
C209 a_2700_6400.n8 VSS 0.09845f
C210 a_2700_6400.n9 VSS 0.09845f
C211 a_2700_6400.n10 VSS 0.09845f
C212 a_2700_6400.n11 VSS 0.05379f
C213 a_2700_6400.n12 VSS 0.30195f
C214 a_2700_6400.n13 VSS 0.05379f
C215 a_2700_6400.n14 VSS 0.18581f
C216 a_2700_6400.n15 VSS 0.09184f
C217 a_2700_6400.n16 VSS 0.09845f
C218 a_2700_6400.n17 VSS 0.09845f
C219 a_2700_6400.n18 VSS 0.09845f
C220 a_2700_6400.n19 VSS 0.09184f
C221 a_2700_6400.n20 VSS 0.18581f
C222 a_2700_6400.n21 VSS 0.09845f
C223 a_2700_6400.n22 VSS 0.09845f
C224 a_2700_6400.n23 VSS 0.09845f
C225 a_2700_6400.n24 VSS 0.05379f
C226 a_2700_6400.n25 VSS 0.22616f
C227 a_2700_6400.n26 VSS 2.10925f
C228 a_2700_6400.t7 VSS 0.781f
C229 a_2700_6400.t6 VSS 0.1765f
C230 a_2700_6400.t5 VSS 0.1765f
C231 a_2700_6400.n27 VSS 0.57755f
C232 a_2700_6400.n28 VSS 0.3255f
C233 a_2700_6400.t4 VSS 0.77577f
C234 a_2700_6400.n29 VSS 0.23422f
C235 a_2700_6400.n30 VSS 1.96271f
C236 a_2700_6400.t0 VSS 0.77717f
C237 a_2700_6400.n31 VSS 0.34542f
C238 a_2700_6400.t2 VSS 0.1765f
C239 a_2700_6400.t1 VSS 0.1765f
C240 a_2700_6400.n32 VSS 0.58184f
C241 a_2700_6400.n33 VSS 0.31982f
C242 a_2700_6400.t3 VSS 0.78239f
C243 a_4812_6400.n0 VSS 0.05444f
C244 a_4812_6400.n1 VSS 0.18807f
C245 a_4812_6400.n2 VSS 0.09296f
C246 a_4812_6400.n3 VSS 0.09965f
C247 a_4812_6400.n4 VSS 0.09965f
C248 a_4812_6400.n5 VSS 0.09965f
C249 a_4812_6400.n6 VSS 0.09296f
C250 a_4812_6400.n7 VSS 0.18807f
C251 a_4812_6400.n8 VSS 0.09965f
C252 a_4812_6400.n9 VSS 0.09965f
C253 a_4812_6400.n10 VSS 0.09965f
C254 a_4812_6400.n11 VSS 0.05444f
C255 a_4812_6400.n12 VSS 0.28276f
C256 a_4812_6400.n13 VSS 0.05444f
C257 a_4812_6400.n14 VSS 0.18807f
C258 a_4812_6400.n15 VSS 0.09296f
C259 a_4812_6400.n16 VSS 0.09965f
C260 a_4812_6400.n17 VSS 0.09965f
C261 a_4812_6400.n18 VSS 0.09965f
C262 a_4812_6400.n19 VSS 0.09296f
C263 a_4812_6400.n20 VSS 0.18807f
C264 a_4812_6400.n21 VSS 0.09965f
C265 a_4812_6400.n22 VSS 0.09965f
C266 a_4812_6400.n23 VSS 0.09965f
C267 a_4812_6400.n24 VSS 0.05444f
C268 a_4812_6400.n25 VSS 0.24144f
C269 a_4812_6400.n26 VSS 2.20235f
C270 a_4812_6400.t7 VSS 0.79057f
C271 a_4812_6400.t6 VSS 0.17869f
C272 a_4812_6400.t5 VSS 0.17869f
C273 a_4812_6400.n27 VSS 0.58459f
C274 a_4812_6400.n28 VSS 0.32947f
C275 a_4812_6400.t4 VSS 0.78527f
C276 a_4812_6400.n29 VSS 0.23707f
C277 a_4812_6400.n30 VSS 1.962f
C278 a_4812_6400.t0 VSS 0.78669f
C279 a_4812_6400.n31 VSS 0.34963f
C280 a_4812_6400.t2 VSS 0.17869f
C281 a_4812_6400.t1 VSS 0.17869f
C282 a_4812_6400.n32 VSS 0.58894f
C283 a_4812_6400.n33 VSS 0.32372f
C284 a_4812_6400.t3 VSS 0.79197f
C285 a_6924_6400.n0 VSS 0.05256f
C286 a_6924_6400.n1 VSS 0.06238f
C287 a_6924_6400.n2 VSS 0.06238f
C288 a_6924_6400.n3 VSS 0.06238f
C289 a_6924_6400.n4 VSS 0.06238f
C290 a_6924_6400.n5 VSS 0.18155f
C291 a_6924_6400.n6 VSS 0.08974f
C292 a_6924_6400.n7 VSS 0.09619f
C293 a_6924_6400.n8 VSS 0.09619f
C294 a_6924_6400.n9 VSS 0.09619f
C295 a_6924_6400.n10 VSS 0.09619f
C296 a_6924_6400.n11 VSS 0.09619f
C297 a_6924_6400.n12 VSS 0.09619f
C298 a_6924_6400.n13 VSS 0.09619f
C299 a_6924_6400.n14 VSS 0.06238f
C300 a_6924_6400.n15 VSS 0.09619f
C301 a_6924_6400.n16 VSS 0.08974f
C302 a_6924_6400.n17 VSS 0.18155f
C303 a_6924_6400.n18 VSS 0.09619f
C304 a_6924_6400.n19 VSS 0.09619f
C305 a_6924_6400.n20 VSS 0.09619f
C306 a_6924_6400.n21 VSS 0.06238f
C307 a_6924_6400.n22 VSS 0.06238f
C308 a_6924_6400.n23 VSS 0.06238f
C309 a_6924_6400.n24 VSS 0.09619f
C310 a_6924_6400.n25 VSS 0.09619f
C311 a_6924_6400.n26 VSS 0.09619f
C312 a_6924_6400.n27 VSS 0.05256f
C313 a_6924_6400.n28 VSS 0.53497f
C314 a_6924_6400.n29 VSS 0.05256f
C315 a_6924_6400.n30 VSS 0.06238f
C316 a_6924_6400.n31 VSS 0.06238f
C317 a_6924_6400.n32 VSS 0.06238f
C318 a_6924_6400.n33 VSS 0.06238f
C319 a_6924_6400.n34 VSS 0.18155f
C320 a_6924_6400.n35 VSS 0.08974f
C321 a_6924_6400.n36 VSS 0.09619f
C322 a_6924_6400.n37 VSS 0.09619f
C323 a_6924_6400.n38 VSS 0.09619f
C324 a_6924_6400.n39 VSS 0.09619f
C325 a_6924_6400.n40 VSS 0.09619f
C326 a_6924_6400.n41 VSS 0.09619f
C327 a_6924_6400.n42 VSS 0.09619f
C328 a_6924_6400.n43 VSS 0.06238f
C329 a_6924_6400.n44 VSS 0.09619f
C330 a_6924_6400.n45 VSS 0.08974f
C331 a_6924_6400.n46 VSS 0.18155f
C332 a_6924_6400.n47 VSS 0.09619f
C333 a_6924_6400.n48 VSS 0.09619f
C334 a_6924_6400.n49 VSS 0.09619f
C335 a_6924_6400.n50 VSS 0.06238f
C336 a_6924_6400.n51 VSS 0.06238f
C337 a_6924_6400.n52 VSS 0.06238f
C338 a_6924_6400.n53 VSS 0.09619f
C339 a_6924_6400.n54 VSS 0.09619f
C340 a_6924_6400.n55 VSS 0.09619f
C341 a_6924_6400.n56 VSS 0.05256f
C342 a_6924_6400.n57 VSS 0.40388f
C343 a_6924_6400.n58 VSS 2.68995f
C344 a_6924_6400.t15 VSS 0.76545f
C345 a_6924_6400.t14 VSS 0.17474f
C346 a_6924_6400.t13 VSS 0.17474f
C347 a_6924_6400.n59 VSS 0.56432f
C348 a_6924_6400.n60 VSS 0.31804f
C349 a_6924_6400.t12 VSS 0.17474f
C350 a_6924_6400.t11 VSS 0.17474f
C351 a_6924_6400.n61 VSS 0.56432f
C352 a_6924_6400.n62 VSS 0.16732f
C353 a_6924_6400.t10 VSS 0.17474f
C354 a_6924_6400.t9 VSS 0.17474f
C355 a_6924_6400.n63 VSS 0.56432f
C356 a_6924_6400.n64 VSS 0.16732f
C357 a_6924_6400.t8 VSS 0.76034f
C358 a_6924_6400.n65 VSS 0.22885f
C359 a_6924_6400.n66 VSS 2.24895f
C360 a_6924_6400.t0 VSS 0.7617f
C361 a_6924_6400.n67 VSS 0.33751f
C362 a_6924_6400.t2 VSS 0.17474f
C363 a_6924_6400.t1 VSS 0.17474f
C364 a_6924_6400.n68 VSS 0.56852f
C365 a_6924_6400.n69 VSS 0.16313f
C366 a_6924_6400.t4 VSS 0.17474f
C367 a_6924_6400.t3 VSS 0.17474f
C368 a_6924_6400.n70 VSS 0.56852f
C369 a_6924_6400.n71 VSS 0.16313f
C370 a_6924_6400.t6 VSS 0.17474f
C371 a_6924_6400.t5 VSS 0.17474f
C372 a_6924_6400.n72 VSS 0.56852f
C373 a_6924_6400.n73 VSS 0.31249f
C374 a_6924_6400.t7 VSS 0.7668f
C375 VSS.t165 VSS 0.09336f
C376 VSS.t107 VSS 0.09515f
C377 VSS.t83 VSS 0.09336f
C378 VSS.t163 VSS 0.09336f
C379 VSS.t21 VSS 0.09336f
C380 VSS.t81 VSS 0.09336f
C381 VSS.t3 VSS 0.09336f
C382 VSS.t19 VSS 0.09336f
C383 VSS.t99 VSS 0.09336f
C384 VSS.t1 VSS 0.09336f
C385 VSS.t17 VSS 0.09336f
C386 VSS.t97 VSS 0.09336f
C387 VSS.t33 VSS 0.09336f
C388 VSS.t15 VSS 0.09336f
C389 VSS.t51 VSS 0.09515f
C390 VSS.t31 VSS 0.09336f
C391 VSS.t167 VSS 0.09672f
C392 VSS.t169 VSS 0.09857f
C393 VSS.t85 VSS 0.09672f
C394 VSS.t87 VSS 0.09672f
C395 VSS.t101 VSS 0.09672f
C396 VSS.t103 VSS 0.09672f
C397 VSS.t43 VSS 0.09857f
C398 VSS.t45 VSS 0.09672f
C399 VSS.t111 VSS 0.09555f
C400 VSS.t181 VSS 0.09738f
C401 VSS.t173 VSS 0.09555f
C402 VSS.t109 VSS 0.09555f
C403 VSS.t91 VSS 0.09555f
C404 VSS.t171 VSS 0.09555f
C405 VSS.t23 VSS 0.09738f
C406 VSS.t89 VSS 0.09555f
C407 VSS.t135 VSS 0.06491f
C408 VSS.t147 VSS 0.06616f
C409 VSS.t151 VSS 0.06491f
C410 VSS.t149 VSS 0.06491f
C411 VSS.t153 VSS 0.06491f
C412 VSS.t143 VSS 0.06491f
C413 VSS.t141 VSS 0.06616f
C414 VSS.t155 VSS 0.06491f
C415 VSS.t137 VSS 0.06491f
C416 VSS.t133 VSS 0.06616f
C417 VSS.t145 VSS 0.06616f
C418 VSS.t139 VSS 0.06491f
C419 VSS.t129 VSS 0.06409f
C420 VSS.t127 VSS 0.06532f
C421 VSS.t125 VSS 0.06532f
C422 VSS.t131 VSS 0.06409f
C423 VSS.t39 VSS 0.06169f
C424 VSS.t37 VSS 0.06287f
C425 VSS.t35 VSS 0.06287f
C426 VSS.t41 VSS 0.06169f
C427 VSS.t57 VSS 0.06491f
C428 VSS.t55 VSS 0.06616f
C429 VSS.t61 VSS 0.06616f
C430 VSS.t59 VSS 0.06491f
C431 VSS.t53 VSS 0.06491f
C432 VSS.t63 VSS 0.06616f
C433 VSS.t67 VSS 0.06491f
C434 VSS.t65 VSS 0.06491f
C435 VSS.t71 VSS 0.06491f
C436 VSS.t69 VSS 0.06491f
C437 VSS.t75 VSS 0.06616f
C438 VSS.t73 VSS 0.06491f
C439 VSS.t159 VSS 0.09555f
C440 VSS.t179 VSS 0.09738f
C441 VSS.t11 VSS 0.09555f
C442 VSS.t157 VSS 0.09555f
C443 VSS.t29 VSS 0.09555f
C444 VSS.t9 VSS 0.09555f
C445 VSS.t161 VSS 0.09738f
C446 VSS.t13 VSS 0.09555f
C447 VSS.t47 VSS 0.09672f
C448 VSS.t49 VSS 0.09857f
C449 VSS.t25 VSS 0.09672f
C450 VSS.t27 VSS 0.09672f
C451 VSS.t5 VSS 0.09672f
C452 VSS.t7 VSS 0.09672f
C453 VSS.t77 VSS 0.09857f
C454 VSS.t79 VSS 0.09672f
C455 VSS.t189 VSS 0.09336f
C456 VSS.t105 VSS 0.09515f
C457 VSS.t119 VSS 0.09336f
C458 VSS.t187 VSS 0.09336f
C459 VSS.t123 VSS 0.09336f
C460 VSS.t117 VSS 0.09336f
C461 VSS.t185 VSS 0.09336f
C462 VSS.t121 VSS 0.09336f
C463 VSS.t115 VSS 0.09336f
C464 VSS.t183 VSS 0.09336f
C465 VSS.t177 VSS 0.09336f
C466 VSS.t113 VSS 0.09336f
C467 VSS.t95 VSS 0.09336f
C468 VSS.t175 VSS 0.09336f
C469 VSS.t191 VSS 0.09515f
C470 VSS.t93 VSS 0.09336f
C471 VDD.n1 VSS 1.02085f
C472 VDD.t140 VSS 0.55707f
C473 VDD.t142 VSS 0.09939f
C474 VDD.t144 VSS 0.09939f
C475 VDD.t146 VSS 0.55658f
C476 VDD.t154 VSS 0.55658f
C477 VDD.t158 VSS 0.09939f
C478 VDD.t152 VSS 0.09939f
C479 VDD.t160 VSS 0.55658f
C480 VDD.t162 VSS 0.55658f
C481 VDD.t148 VSS 0.09939f
C482 VDD.t164 VSS 0.09939f
C483 VDD.t166 VSS 0.09939f
C484 VDD.t156 VSS 0.09939f
C485 VDD.t168 VSS 0.09939f
C486 VDD.t170 VSS 0.09939f
C487 VDD.t150 VSS 0.55658f
C488 VDD.t108 VSS 0.55658f
C489 VDD.t120 VSS 0.09939f
C490 VDD.t118 VSS 0.09939f
C491 VDD.t42 VSS 0.09939f
C492 VDD.t40 VSS 0.09939f
C493 VDD.t50 VSS 0.09939f
C494 VDD.t48 VSS 0.09939f
C495 VDD.t182 VSS 0.55658f
C496 VDD.t8 VSS 0.55658f
C497 VDD.t6 VSS 0.09939f
C498 VDD.t30 VSS 0.09939f
C499 VDD.t28 VSS 0.09939f
C500 VDD.t86 VSS 0.09939f
C501 VDD.t84 VSS 0.09939f
C502 VDD.t94 VSS 0.09939f
C503 VDD.t92 VSS 0.55658f
C504 VDD.t0 VSS 0.55658f
C505 VDD.t4 VSS 0.09939f
C506 VDD.t2 VSS 0.09939f
C507 VDD.t26 VSS 0.09939f
C508 VDD.t24 VSS 0.09939f
C509 VDD.t90 VSS 0.09939f
C510 VDD.t88 VSS 0.09939f
C511 VDD.t174 VSS 0.09939f
C512 VDD.t172 VSS 0.09939f
C513 VDD.t106 VSS 0.09939f
C514 VDD.t104 VSS 0.09939f
C515 VDD.t116 VSS 0.09939f
C516 VDD.t114 VSS 0.09939f
C517 VDD.t46 VSS 0.09939f
C518 VDD.t44 VSS 0.09939f
C519 VDD.t124 VSS 0.50108f
C520 VDD.n2 VSS 2.35338f
C521 VDD.t5 VSS 0.1005f
C522 VDD.t1 VSS 0.10229f
C523 VDD.n3 VSS 0.03724f
C524 VDD.t27 VSS 0.1005f
C525 VDD.t3 VSS 0.1005f
C526 VDD.n4 VSS 0.03695f
C527 VDD.n5 VSS 0.01873f
C528 VDD.t91 VSS 0.1005f
C529 VDD.t25 VSS 0.1005f
C530 VDD.n6 VSS 0.03695f
C531 VDD.n7 VSS 0.0106f
C532 VDD.t175 VSS 0.1005f
C533 VDD.t89 VSS 0.1005f
C534 VDD.n8 VSS 0.03695f
C535 VDD.n9 VSS 0.0106f
C536 VDD.t107 VSS 0.1005f
C537 VDD.t173 VSS 0.1005f
C538 VDD.n10 VSS 0.03695f
C539 VDD.n11 VSS 0.0106f
C540 VDD.t117 VSS 0.1005f
C541 VDD.t105 VSS 0.1005f
C542 VDD.n12 VSS 0.03695f
C543 VDD.n13 VSS 0.0106f
C544 VDD.t47 VSS 0.1005f
C545 VDD.t115 VSS 0.1005f
C546 VDD.n14 VSS 0.03695f
C547 VDD.n15 VSS 0.0106f
C548 VDD.t125 VSS 0.10229f
C549 VDD.t45 VSS 0.1005f
C550 VDD.n16 VSS 0.03695f
C551 VDD.n17 VSS 0.04139f
C552 VDD.n18 VSS 0.31692f
C553 VDD.t7 VSS 0.10385f
C554 VDD.t9 VSS 0.10571f
C555 VDD.n19 VSS 0.03724f
C556 VDD.t29 VSS 0.10385f
C557 VDD.t31 VSS 0.10385f
C558 VDD.n20 VSS 0.03695f
C559 VDD.n21 VSS 0.01873f
C560 VDD.t85 VSS 0.10385f
C561 VDD.t87 VSS 0.10385f
C562 VDD.n22 VSS 0.03695f
C563 VDD.n23 VSS 0.0106f
C564 VDD.t93 VSS 0.10571f
C565 VDD.t95 VSS 0.10385f
C566 VDD.n24 VSS 0.03695f
C567 VDD.n25 VSS 0.04139f
C568 VDD.n26 VSS 0.49074f
C569 VDD.t121 VSS 0.10269f
C570 VDD.t109 VSS 0.10452f
C571 VDD.n27 VSS 0.03724f
C572 VDD.t43 VSS 0.10269f
C573 VDD.t119 VSS 0.10269f
C574 VDD.n28 VSS 0.03695f
C575 VDD.n29 VSS 0.01873f
C576 VDD.t51 VSS 0.10269f
C577 VDD.t41 VSS 0.10269f
C578 VDD.n30 VSS 0.03695f
C579 VDD.n31 VSS 0.0106f
C580 VDD.t183 VSS 0.10452f
C581 VDD.t49 VSS 0.10269f
C582 VDD.n32 VSS 0.03695f
C583 VDD.n33 VSS 0.04139f
C584 VDD.n34 VSS 0.40288f
C585 VDD.t149 VSS 0.07205f
C586 VDD.t163 VSS 0.0733f
C587 VDD.n35 VSS 0.03724f
C588 VDD.t167 VSS 0.07205f
C589 VDD.t165 VSS 0.07205f
C590 VDD.n36 VSS 0.03695f
C591 VDD.n37 VSS 0.01873f
C592 VDD.t169 VSS 0.07205f
C593 VDD.t157 VSS 0.07205f
C594 VDD.n38 VSS 0.03695f
C595 VDD.n39 VSS 0.0106f
C596 VDD.t151 VSS 0.0733f
C597 VDD.t171 VSS 0.07205f
C598 VDD.n40 VSS 0.03695f
C599 VDD.n41 VSS 0.04139f
C600 VDD.n42 VSS 0.40288f
C601 VDD.t159 VSS 0.07205f
C602 VDD.t155 VSS 0.0733f
C603 VDD.n43 VSS 0.03724f
C604 VDD.t161 VSS 0.0733f
C605 VDD.t153 VSS 0.07205f
C606 VDD.n44 VSS 0.03695f
C607 VDD.n45 VSS 0.04951f
C608 VDD.n46 VSS 0.35895f
C609 VDD.t143 VSS 0.07123f
C610 VDD.t141 VSS 0.07246f
C611 VDD.n47 VSS 0.03724f
C612 VDD.t147 VSS 0.07246f
C613 VDD.t145 VSS 0.07123f
C614 VDD.n48 VSS 0.03695f
C615 VDD.n49 VSS 0.04951f
C616 VDD.n50 VSS 0.31434f
C617 VDD.n51 VSS 0.1484f
C618 VDD.n52 VSS 3.46671f
C619 VDD.n53 VSS 21.5055f
C620 VDD.n54 VSS 45.3582f
C621 VDD.n55 VSS 1.02085f
C622 VDD.t34 VSS 0.55707f
C623 VDD.t36 VSS 0.09939f
C624 VDD.t38 VSS 0.09939f
C625 VDD.t32 VSS 0.55658f
C626 VDD.t60 VSS 0.55658f
C627 VDD.t62 VSS 0.09939f
C628 VDD.t58 VSS 0.09939f
C629 VDD.t64 VSS 0.55658f
C630 VDD.t66 VSS 0.55658f
C631 VDD.t56 VSS 0.09939f
C632 VDD.t68 VSS 0.09939f
C633 VDD.t70 VSS 0.09939f
C634 VDD.t74 VSS 0.09939f
C635 VDD.t76 VSS 0.09939f
C636 VDD.t78 VSS 0.09939f
C637 VDD.t72 VSS 0.55658f
C638 VDD.t18 VSS 0.55658f
C639 VDD.t102 VSS 0.09939f
C640 VDD.t100 VSS 0.09939f
C641 VDD.t54 VSS 0.09939f
C642 VDD.t52 VSS 0.09939f
C643 VDD.t82 VSS 0.09939f
C644 VDD.t80 VSS 0.09939f
C645 VDD.t180 VSS 0.55658f
C646 VDD.t12 VSS 0.55658f
C647 VDD.t10 VSS 0.09939f
C648 VDD.t98 VSS 0.09939f
C649 VDD.t96 VSS 0.09939f
C650 VDD.t22 VSS 0.09939f
C651 VDD.t20 VSS 0.09939f
C652 VDD.t16 VSS 0.09939f
C653 VDD.t14 VSS 0.55658f
C654 VDD.t134 VSS 0.55658f
C655 VDD.t186 VSS 0.09939f
C656 VDD.t184 VSS 0.09939f
C657 VDD.t128 VSS 0.09939f
C658 VDD.t126 VSS 0.09939f
C659 VDD.t132 VSS 0.09939f
C660 VDD.t130 VSS 0.09939f
C661 VDD.t138 VSS 0.09939f
C662 VDD.t136 VSS 0.09939f
C663 VDD.t178 VSS 0.09939f
C664 VDD.t176 VSS 0.09939f
C665 VDD.t112 VSS 0.09939f
C666 VDD.t110 VSS 0.09939f
C667 VDD.t190 VSS 0.09939f
C668 VDD.t188 VSS 0.09939f
C669 VDD.t122 VSS 0.50108f
C670 VDD.n56 VSS 2.35338f
C671 VDD.t187 VSS 0.1005f
C672 VDD.t135 VSS 0.10229f
C673 VDD.n57 VSS 0.03724f
C674 VDD.t129 VSS 0.1005f
C675 VDD.t185 VSS 0.1005f
C676 VDD.n58 VSS 0.03695f
C677 VDD.n59 VSS 0.01873f
C678 VDD.t133 VSS 0.1005f
C679 VDD.t127 VSS 0.1005f
C680 VDD.n60 VSS 0.03695f
C681 VDD.n61 VSS 0.0106f
C682 VDD.t139 VSS 0.1005f
C683 VDD.t131 VSS 0.1005f
C684 VDD.n62 VSS 0.03695f
C685 VDD.n63 VSS 0.0106f
C686 VDD.t179 VSS 0.1005f
C687 VDD.t137 VSS 0.1005f
C688 VDD.n64 VSS 0.03695f
C689 VDD.n65 VSS 0.0106f
C690 VDD.t113 VSS 0.1005f
C691 VDD.t177 VSS 0.1005f
C692 VDD.n66 VSS 0.03695f
C693 VDD.n67 VSS 0.0106f
C694 VDD.t191 VSS 0.1005f
C695 VDD.t111 VSS 0.1005f
C696 VDD.n68 VSS 0.03695f
C697 VDD.n69 VSS 0.0106f
C698 VDD.t123 VSS 0.10229f
C699 VDD.t189 VSS 0.1005f
C700 VDD.n70 VSS 0.03695f
C701 VDD.n71 VSS 0.04139f
C702 VDD.n72 VSS 0.31692f
C703 VDD.t11 VSS 0.10385f
C704 VDD.t13 VSS 0.10571f
C705 VDD.n73 VSS 0.03724f
C706 VDD.t97 VSS 0.10385f
C707 VDD.t99 VSS 0.10385f
C708 VDD.n74 VSS 0.03695f
C709 VDD.n75 VSS 0.01873f
C710 VDD.t21 VSS 0.10385f
C711 VDD.t23 VSS 0.10385f
C712 VDD.n76 VSS 0.03695f
C713 VDD.n77 VSS 0.0106f
C714 VDD.t15 VSS 0.10571f
C715 VDD.t17 VSS 0.10385f
C716 VDD.n78 VSS 0.03695f
C717 VDD.n79 VSS 0.04139f
C718 VDD.n80 VSS 0.49074f
C719 VDD.t103 VSS 0.10269f
C720 VDD.t19 VSS 0.10452f
C721 VDD.n81 VSS 0.03724f
C722 VDD.t55 VSS 0.10269f
C723 VDD.t101 VSS 0.10269f
C724 VDD.n82 VSS 0.03695f
C725 VDD.n83 VSS 0.01873f
C726 VDD.t83 VSS 0.10269f
C727 VDD.t53 VSS 0.10269f
C728 VDD.n84 VSS 0.03695f
C729 VDD.n85 VSS 0.0106f
C730 VDD.t181 VSS 0.10452f
C731 VDD.t81 VSS 0.10269f
C732 VDD.n86 VSS 0.03695f
C733 VDD.n87 VSS 0.04139f
C734 VDD.n88 VSS 0.40288f
C735 VDD.t57 VSS 0.07205f
C736 VDD.t67 VSS 0.0733f
C737 VDD.n89 VSS 0.03724f
C738 VDD.t71 VSS 0.07205f
C739 VDD.t69 VSS 0.07205f
C740 VDD.n90 VSS 0.03695f
C741 VDD.n91 VSS 0.01873f
C742 VDD.t77 VSS 0.07205f
C743 VDD.t75 VSS 0.07205f
C744 VDD.n92 VSS 0.03695f
C745 VDD.n93 VSS 0.0106f
C746 VDD.t73 VSS 0.0733f
C747 VDD.t79 VSS 0.07205f
C748 VDD.n94 VSS 0.03695f
C749 VDD.n95 VSS 0.04139f
C750 VDD.n96 VSS 0.40288f
C751 VDD.t63 VSS 0.07205f
C752 VDD.t61 VSS 0.0733f
C753 VDD.n97 VSS 0.03724f
C754 VDD.t65 VSS 0.0733f
C755 VDD.t59 VSS 0.07205f
C756 VDD.n98 VSS 0.03695f
C757 VDD.n99 VSS 0.04951f
C758 VDD.n100 VSS 0.35895f
C759 VDD.t37 VSS 0.06883f
C760 VDD.t35 VSS 0.07001f
C761 VDD.n101 VSS 0.03724f
C762 VDD.t33 VSS 0.07001f
C763 VDD.t39 VSS 0.06883f
C764 VDD.n102 VSS 0.03695f
C765 VDD.n103 VSS 0.04951f
C766 VDD.n104 VSS 0.31434f
C767 VDD.n105 VSS 0.1484f
C768 VDD.n106 VSS 3.46671f
C769 VDD.n107 VSS 21.1974f
C770 VDD.n108 VSS 45.6662f
C771 CLKN_HB.n0 VSS 0.05845f
C772 CLKN_HB.n1 VSS 0.06356f
C773 CLKN_HB.n2 VSS 0.06356f
C774 CLKN_HB.n3 VSS 0.05845f
C775 CLKN_HB.n4 VSS 0.27899f
C776 CLKN_HB.n5 VSS 0.05845f
C777 CLKN_HB.n6 VSS 0.06356f
C778 CLKN_HB.n7 VSS 0.06356f
C779 CLKN_HB.n8 VSS 0.05845f
C780 CLKN_HB.n9 VSS 0.22548f
C781 CLKN_HB.n10 VSS 0.96729f
C782 CLKN_H.n0 VSS 0.03654f
C783 CLKN_H.n1 VSS 0.12623f
C784 CLKN_H.n2 VSS 0.06239f
C785 CLKN_H.n3 VSS 0.06688f
C786 CLKN_H.n4 VSS 0.06688f
C787 CLKN_H.n5 VSS 0.06688f
C788 CLKN_H.n6 VSS 0.06239f
C789 CLKN_H.n7 VSS 0.12623f
C790 CLKN_H.n8 VSS 0.06688f
C791 CLKN_H.n9 VSS 0.06688f
C792 CLKN_H.n10 VSS 0.06688f
C793 CLKN_H.n11 VSS 0.03654f
C794 CLKN_H.n12 VSS 0.21715f
C795 CLKN_H.n13 VSS 0.03654f
C796 CLKN_H.n14 VSS 0.12623f
C797 CLKN_H.n15 VSS 0.06239f
C798 CLKN_H.n16 VSS 0.06688f
C799 CLKN_H.n17 VSS 0.06688f
C800 CLKN_H.n18 VSS 0.06688f
C801 CLKN_H.n19 VSS 0.06239f
C802 CLKN_H.n20 VSS 0.12623f
C803 CLKN_H.n21 VSS 0.06688f
C804 CLKN_H.n22 VSS 0.06688f
C805 CLKN_H.n23 VSS 0.06688f
C806 CLKN_H.n24 VSS 0.03654f
C807 CLKN_H.n25 VSS 0.14923f
C808 CLKN_H.n26 VSS 1.90949f
C809 CLKN_H.n27 VSS 0.06151f
C810 CLKN_H.n28 VSS 0.06688f
C811 CLKN_H.n29 VSS 0.06688f
C812 CLKN_H.n30 VSS 0.06151f
C813 CLKN_H.n31 VSS 0.29359f
C814 CLKN_H.n32 VSS 0.06151f
C815 CLKN_H.n33 VSS 0.06688f
C816 CLKN_H.n34 VSS 0.06688f
C817 CLKN_H.n35 VSS 0.06151f
C818 CLKN_H.n36 VSS 0.23728f
C819 CLKN_H.n37 VSS 1.76131f
C820 CLKN_H.n38 VSS 1.67956f
C821 O_CAPTURE_CLKB.t15 VSS 1.04198f
C822 O_CAPTURE_CLKB.t7 VSS 0.24362f
C823 O_CAPTURE_CLKB.t8 VSS 0.24362f
C824 O_CAPTURE_CLKB.n0 VSS 0.76646f
C825 O_CAPTURE_CLKB.n1 VSS 0.4213f
C826 O_CAPTURE_CLKB.t5 VSS 0.24362f
C827 O_CAPTURE_CLKB.t6 VSS 0.24362f
C828 O_CAPTURE_CLKB.n2 VSS 0.76646f
C829 O_CAPTURE_CLKB.n3 VSS 0.21993f
C830 O_CAPTURE_CLKB.t9 VSS 0.24362f
C831 O_CAPTURE_CLKB.t10 VSS 0.24362f
C832 O_CAPTURE_CLKB.n4 VSS 0.76646f
C833 O_CAPTURE_CLKB.n5 VSS 0.21993f
C834 O_CAPTURE_CLKB.t3 VSS 1.0351f
C835 O_CAPTURE_CLKB.n6 VSS 0.45502f
C836 O_CAPTURE_CLKB.t13 VSS 1.04015f
C837 O_CAPTURE_CLKB.t2 VSS 0.24362f
C838 O_CAPTURE_CLKB.t4 VSS 0.24362f
C839 O_CAPTURE_CLKB.n7 VSS 0.76081f
C840 O_CAPTURE_CLKB.n8 VSS 0.42878f
C841 O_CAPTURE_CLKB.t0 VSS 0.24362f
C842 O_CAPTURE_CLKB.t1 VSS 0.24362f
C843 O_CAPTURE_CLKB.n9 VSS 0.76081f
C844 O_CAPTURE_CLKB.n10 VSS 0.22558f
C845 O_CAPTURE_CLKB.t11 VSS 0.24362f
C846 O_CAPTURE_CLKB.t12 VSS 0.24362f
C847 O_CAPTURE_CLKB.n11 VSS 0.76081f
C848 O_CAPTURE_CLKB.n12 VSS 0.22558f
C849 O_CAPTURE_CLKB.t14 VSS 1.03326f
C850 O_CAPTURE_CLKB.n13 VSS 0.30854f
C851 O_CAPTURE_CLKB.n14 VSS 1.14602f
C852 O_CAPTURE_CLK.t4 VSS 1.037f
C853 O_CAPTURE_CLK.t5 VSS 0.24382f
C854 O_CAPTURE_CLK.t8 VSS 0.24382f
C855 O_CAPTURE_CLK.n0 VSS 0.76145f
C856 O_CAPTURE_CLK.n1 VSS 0.41855f
C857 O_CAPTURE_CLK.t9 VSS 0.24382f
C858 O_CAPTURE_CLK.t14 VSS 0.24382f
C859 O_CAPTURE_CLK.n2 VSS 0.76145f
C860 O_CAPTURE_CLK.n3 VSS 0.21849f
C861 O_CAPTURE_CLK.t15 VSS 0.24382f
C862 O_CAPTURE_CLK.t2 VSS 0.24382f
C863 O_CAPTURE_CLK.n4 VSS 0.76145f
C864 O_CAPTURE_CLK.n5 VSS 0.21849f
C865 O_CAPTURE_CLK.t3 VSS 1.03016f
C866 O_CAPTURE_CLK.n6 VSS 0.45205f
C867 O_CAPTURE_CLK.t12 VSS 1.03518f
C868 O_CAPTURE_CLK.t13 VSS 0.24382f
C869 O_CAPTURE_CLK.t0 VSS 0.24382f
C870 O_CAPTURE_CLK.n7 VSS 0.75584f
C871 O_CAPTURE_CLK.n8 VSS 0.42598f
C872 O_CAPTURE_CLK.t1 VSS 0.24382f
C873 O_CAPTURE_CLK.t6 VSS 0.24382f
C874 O_CAPTURE_CLK.n9 VSS 0.75584f
C875 O_CAPTURE_CLK.n10 VSS 0.22411f
C876 O_CAPTURE_CLK.t7 VSS 0.24382f
C877 O_CAPTURE_CLK.t10 VSS 0.24382f
C878 O_CAPTURE_CLK.n11 VSS 0.75584f
C879 O_CAPTURE_CLK.n12 VSS 0.22411f
C880 O_CAPTURE_CLK.t11 VSS 1.02833f
C881 O_CAPTURE_CLK.n13 VSS 0.30652f
C882 O_CAPTURE_CLK.n14 VSS 0.98368f
C883 O_SENSE.t5 VSS 1.05882f
C884 O_SENSE.t29 VSS 0.24442f
C885 O_SENSE.t30 VSS 0.24442f
C886 O_SENSE.n0 VSS 0.78194f
C887 O_SENSE.n1 VSS 0.42981f
C888 O_SENSE.t0 VSS 0.24442f
C889 O_SENSE.t1 VSS 0.24442f
C890 O_SENSE.n2 VSS 0.78194f
C891 O_SENSE.n3 VSS 0.22437f
C892 O_SENSE.t19 VSS 0.24442f
C893 O_SENSE.t20 VSS 0.24442f
C894 O_SENSE.n4 VSS 0.78194f
C895 O_SENSE.n5 VSS 0.22437f
C896 O_SENSE.t15 VSS 0.24442f
C897 O_SENSE.t16 VSS 0.24442f
C898 O_SENSE.n6 VSS 0.78194f
C899 O_SENSE.n7 VSS 0.22437f
C900 O_SENSE.t10 VSS 0.24442f
C901 O_SENSE.t11 VSS 0.24442f
C902 O_SENSE.n8 VSS 0.78194f
C903 O_SENSE.n9 VSS 0.22437f
C904 O_SENSE.t6 VSS 0.24442f
C905 O_SENSE.t7 VSS 0.24442f
C906 O_SENSE.n10 VSS 0.78194f
C907 O_SENSE.n11 VSS 0.22437f
C908 O_SENSE.t25 VSS 0.24442f
C909 O_SENSE.t26 VSS 0.24442f
C910 O_SENSE.n12 VSS 0.78194f
C911 O_SENSE.n13 VSS 0.22437f
C912 O_SENSE.t14 VSS 1.05181f
C913 O_SENSE.n14 VSS 0.46421f
C914 O_SENSE.t31 VSS 1.05695f
C915 O_SENSE.t2 VSS 0.24442f
C916 O_SENSE.t3 VSS 0.24442f
C917 O_SENSE.n15 VSS 0.77617f
C918 O_SENSE.n16 VSS 0.43744f
C919 O_SENSE.t21 VSS 0.24442f
C920 O_SENSE.t22 VSS 0.24442f
C921 O_SENSE.n17 VSS 0.77617f
C922 O_SENSE.n18 VSS 0.23013f
C923 O_SENSE.t8 VSS 0.24442f
C924 O_SENSE.t9 VSS 0.24442f
C925 O_SENSE.n19 VSS 0.77617f
C926 O_SENSE.n20 VSS 0.23013f
C927 O_SENSE.t23 VSS 0.24442f
C928 O_SENSE.t24 VSS 0.24442f
C929 O_SENSE.n21 VSS 0.77617f
C930 O_SENSE.n22 VSS 0.23013f
C931 O_SENSE.t17 VSS 0.24442f
C932 O_SENSE.t18 VSS 0.24442f
C933 O_SENSE.n23 VSS 0.77617f
C934 O_SENSE.n24 VSS 0.23013f
C935 O_SENSE.t12 VSS 0.24442f
C936 O_SENSE.t13 VSS 0.24442f
C937 O_SENSE.n25 VSS 0.77617f
C938 O_SENSE.n26 VSS 0.23013f
C939 O_SENSE.t27 VSS 0.24442f
C940 O_SENSE.t28 VSS 0.24442f
C941 O_SENSE.n27 VSS 0.77617f
C942 O_SENSE.n28 VSS 0.23013f
C943 O_SENSE.t4 VSS 1.04993f
C944 O_SENSE.n29 VSS 0.31477f
C945 O_SENSE.n30 VSS 1.59448f
C946 CLKP_HB.n0 VSS 0.06073f
C947 CLKP_HB.n1 VSS 0.06603f
C948 CLKP_HB.n2 VSS 0.06603f
C949 CLKP_HB.n3 VSS 0.06073f
C950 CLKP_HB.n4 VSS 0.28987f
C951 CLKP_HB.n5 VSS 0.06073f
C952 CLKP_HB.n6 VSS 0.06603f
C953 CLKP_HB.n7 VSS 0.06603f
C954 CLKP_HB.n8 VSS 0.06073f
C955 CLKP_HB.n9 VSS 0.23428f
C956 CLKP_HB.n10 VSS 0.93888f
C957 CLKP_H.n0 VSS 0.03654f
C958 CLKP_H.n1 VSS 0.12623f
C959 CLKP_H.n2 VSS 0.06239f
C960 CLKP_H.n3 VSS 0.06688f
C961 CLKP_H.n4 VSS 0.06688f
C962 CLKP_H.n5 VSS 0.06688f
C963 CLKP_H.n6 VSS 0.06239f
C964 CLKP_H.n7 VSS 0.12623f
C965 CLKP_H.n8 VSS 0.06688f
C966 CLKP_H.n9 VSS 0.06688f
C967 CLKP_H.n10 VSS 0.06688f
C968 CLKP_H.n11 VSS 0.03654f
C969 CLKP_H.n12 VSS 0.21715f
C970 CLKP_H.n13 VSS 0.03654f
C971 CLKP_H.n14 VSS 0.12623f
C972 CLKP_H.n15 VSS 0.06239f
C973 CLKP_H.n16 VSS 0.06688f
C974 CLKP_H.n17 VSS 0.06688f
C975 CLKP_H.n18 VSS 0.06688f
C976 CLKP_H.n19 VSS 0.06239f
C977 CLKP_H.n20 VSS 0.12623f
C978 CLKP_H.n21 VSS 0.06688f
C979 CLKP_H.n22 VSS 0.06688f
C980 CLKP_H.n23 VSS 0.06688f
C981 CLKP_H.n24 VSS 0.03654f
C982 CLKP_H.n25 VSS 0.14923f
C983 CLKP_H.n26 VSS 1.90949f
C984 CLKP_H.n27 VSS 0.06151f
C985 CLKP_H.n28 VSS 0.06688f
C986 CLKP_H.n29 VSS 0.06688f
C987 CLKP_H.n30 VSS 0.06151f
C988 CLKP_H.n31 VSS 0.29359f
C989 CLKP_H.n32 VSS 0.06151f
C990 CLKP_H.n33 VSS 0.06688f
C991 CLKP_H.n34 VSS 0.06688f
C992 CLKP_H.n35 VSS 0.06151f
C993 CLKP_H.n36 VSS 0.23728f
C994 CLKP_H.n37 VSS 1.76131f
C995 CLKP_H.n38 VSS 1.67956f
C996 E_CAPTURE_CLKB.t15 VSS 1.04198f
C997 E_CAPTURE_CLKB.t3 VSS 0.24362f
C998 E_CAPTURE_CLKB.t4 VSS 0.24362f
C999 E_CAPTURE_CLKB.n0 VSS 0.76646f
C1000 E_CAPTURE_CLKB.n1 VSS 0.4213f
C1001 E_CAPTURE_CLKB.t1 VSS 0.24362f
C1002 E_CAPTURE_CLKB.t2 VSS 0.24362f
C1003 E_CAPTURE_CLKB.n2 VSS 0.76646f
C1004 E_CAPTURE_CLKB.n3 VSS 0.21993f
C1005 E_CAPTURE_CLKB.t8 VSS 0.24362f
C1006 E_CAPTURE_CLKB.t9 VSS 0.24362f
C1007 E_CAPTURE_CLKB.n4 VSS 0.76646f
C1008 E_CAPTURE_CLKB.n5 VSS 0.21993f
C1009 E_CAPTURE_CLKB.t5 VSS 1.0351f
C1010 E_CAPTURE_CLKB.n6 VSS 0.45502f
C1011 E_CAPTURE_CLKB.t0 VSS 1.04015f
C1012 E_CAPTURE_CLKB.t6 VSS 0.24362f
C1013 E_CAPTURE_CLKB.t7 VSS 0.24362f
C1014 E_CAPTURE_CLKB.n7 VSS 0.76081f
C1015 E_CAPTURE_CLKB.n8 VSS 0.42878f
C1016 E_CAPTURE_CLKB.t12 VSS 0.24362f
C1017 E_CAPTURE_CLKB.t13 VSS 0.24362f
C1018 E_CAPTURE_CLKB.n9 VSS 0.76081f
C1019 E_CAPTURE_CLKB.n10 VSS 0.22558f
C1020 E_CAPTURE_CLKB.t10 VSS 0.24362f
C1021 E_CAPTURE_CLKB.t11 VSS 0.24362f
C1022 E_CAPTURE_CLKB.n11 VSS 0.76081f
C1023 E_CAPTURE_CLKB.n12 VSS 0.22558f
C1024 E_CAPTURE_CLKB.t14 VSS 1.03326f
C1025 E_CAPTURE_CLKB.n13 VSS 0.30854f
C1026 E_CAPTURE_CLKB.n14 VSS 1.14602f
C1027 E_CAPTURE_CLK.t8 VSS 1.037f
C1028 E_CAPTURE_CLK.t9 VSS 0.24382f
C1029 E_CAPTURE_CLK.t6 VSS 0.24382f
C1030 E_CAPTURE_CLK.n0 VSS 0.76145f
C1031 E_CAPTURE_CLK.n1 VSS 0.41855f
C1032 E_CAPTURE_CLK.t7 VSS 0.24382f
C1033 E_CAPTURE_CLK.t2 VSS 0.24382f
C1034 E_CAPTURE_CLK.n2 VSS 0.76145f
C1035 E_CAPTURE_CLK.n3 VSS 0.21849f
C1036 E_CAPTURE_CLK.t3 VSS 0.24382f
C1037 E_CAPTURE_CLK.t0 VSS 0.24382f
C1038 E_CAPTURE_CLK.n4 VSS 0.76145f
C1039 E_CAPTURE_CLK.n5 VSS 0.21849f
C1040 E_CAPTURE_CLK.t1 VSS 1.03016f
C1041 E_CAPTURE_CLK.n6 VSS 0.45205f
C1042 E_CAPTURE_CLK.t4 VSS 1.03518f
C1043 E_CAPTURE_CLK.t5 VSS 0.24382f
C1044 E_CAPTURE_CLK.t12 VSS 0.24382f
C1045 E_CAPTURE_CLK.n7 VSS 0.75584f
C1046 E_CAPTURE_CLK.n8 VSS 0.42598f
C1047 E_CAPTURE_CLK.t13 VSS 0.24382f
C1048 E_CAPTURE_CLK.t10 VSS 0.24382f
C1049 E_CAPTURE_CLK.n9 VSS 0.75584f
C1050 E_CAPTURE_CLK.n10 VSS 0.22411f
C1051 E_CAPTURE_CLK.t11 VSS 0.24382f
C1052 E_CAPTURE_CLK.t14 VSS 0.24382f
C1053 E_CAPTURE_CLK.n11 VSS 0.75584f
C1054 E_CAPTURE_CLK.n12 VSS 0.22411f
C1055 E_CAPTURE_CLK.t15 VSS 1.02833f
C1056 E_CAPTURE_CLK.n13 VSS 0.30652f
C1057 E_CAPTURE_CLK.n14 VSS 0.98368f
C1058 E_SENSE.t27 VSS 1.05882f
C1059 E_SENSE.t13 VSS 0.24442f
C1060 E_SENSE.t14 VSS 0.24442f
C1061 E_SENSE.n0 VSS 0.78194f
C1062 E_SENSE.n1 VSS 0.42981f
C1063 E_SENSE.t22 VSS 0.24442f
C1064 E_SENSE.t23 VSS 0.24442f
C1065 E_SENSE.n2 VSS 0.78194f
C1066 E_SENSE.n3 VSS 0.22437f
C1067 E_SENSE.t18 VSS 0.24442f
C1068 E_SENSE.t19 VSS 0.24442f
C1069 E_SENSE.n4 VSS 0.78194f
C1070 E_SENSE.n5 VSS 0.22437f
C1071 E_SENSE.t28 VSS 0.24442f
C1072 E_SENSE.t29 VSS 0.24442f
C1073 E_SENSE.n6 VSS 0.78194f
C1074 E_SENSE.n7 VSS 0.22437f
C1075 E_SENSE.t16 VSS 0.24442f
C1076 E_SENSE.t17 VSS 0.24442f
C1077 E_SENSE.n8 VSS 0.78194f
C1078 E_SENSE.n9 VSS 0.22437f
C1079 E_SENSE.t9 VSS 0.24442f
C1080 E_SENSE.t10 VSS 0.24442f
C1081 E_SENSE.n10 VSS 0.78194f
C1082 E_SENSE.n11 VSS 0.22437f
C1083 E_SENSE.t3 VSS 0.24442f
C1084 E_SENSE.t4 VSS 0.24442f
C1085 E_SENSE.n12 VSS 0.78194f
C1086 E_SENSE.n13 VSS 0.22437f
C1087 E_SENSE.t0 VSS 1.05181f
C1088 E_SENSE.n14 VSS 0.46421f
C1089 E_SENSE.t15 VSS 1.05695f
C1090 E_SENSE.t11 VSS 0.24442f
C1091 E_SENSE.t12 VSS 0.24442f
C1092 E_SENSE.n15 VSS 0.77617f
C1093 E_SENSE.n16 VSS 0.43744f
C1094 E_SENSE.t5 VSS 0.24442f
C1095 E_SENSE.t6 VSS 0.24442f
C1096 E_SENSE.n17 VSS 0.77617f
C1097 E_SENSE.n18 VSS 0.23013f
C1098 E_SENSE.t24 VSS 0.24442f
C1099 E_SENSE.t25 VSS 0.24442f
C1100 E_SENSE.n19 VSS 0.77617f
C1101 E_SENSE.n20 VSS 0.23013f
C1102 E_SENSE.t1 VSS 0.24442f
C1103 E_SENSE.t2 VSS 0.24442f
C1104 E_SENSE.n21 VSS 0.77617f
C1105 E_SENSE.n22 VSS 0.23013f
C1106 E_SENSE.t7 VSS 0.24442f
C1107 E_SENSE.t8 VSS 0.24442f
C1108 E_SENSE.n23 VSS 0.77617f
C1109 E_SENSE.n24 VSS 0.23013f
C1110 E_SENSE.t20 VSS 0.24442f
C1111 E_SENSE.t21 VSS 0.24442f
C1112 E_SENSE.n25 VSS 0.77617f
C1113 E_SENSE.n26 VSS 0.23013f
C1114 E_SENSE.t30 VSS 0.24442f
C1115 E_SENSE.t31 VSS 0.24442f
C1116 E_SENSE.n27 VSS 0.77617f
C1117 E_SENSE.n28 VSS 0.23013f
C1118 E_SENSE.t26 VSS 1.04993f
C1119 E_SENSE.n29 VSS 0.31477f
C1120 E_SENSE.n30 VSS 1.59448f
.ends
