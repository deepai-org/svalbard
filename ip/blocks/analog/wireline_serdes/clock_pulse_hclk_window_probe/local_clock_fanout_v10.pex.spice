* PEX produced using /foss/tools/sak/sak-pex.sh with m=3 and s=1 (extresist threshold=0 mOhm, minres=1 mOhm, mindelay=0 ps)
* NGSPICE file created from local_clock_fanout_pex.ext - technology: gf180mcuD

.subckt local_clock_fanout_pex CLKP_H CLKP_HB CLKN_H CLKN_HB VDD VSS E_SENSE E_CAPTURE_CLK
+ E_CAPTURE_CLKB O_SENSE O_CAPTURE_CLK O_CAPTURE_CLKB
X0 E_SENSE.t68 a_21324_6400.t120 VSS.t401 VSS.t400 nfet_03v3 ad=2.08p pd=8.52u as=2.08p ps=8.52u w=8u l=0.28u
X1 E_CAPTURE_CLKB.t6 a_2700_6400.t8 VSS.t157 VSS.t156 nfet_03v3 ad=3.52p pd=16.88u as=2.08p ps=8.52u w=8u l=0.28u
X2 VDD.t457 a_21324_6400.t187 E_SENSE.t45 VDD.t456 pfet_03v3 ad=2.08p pd=8.52u as=2.08p ps=8.52u w=8u l=0.28u
X3 O_SENSE.t115 a_21324_41600.t188 VDD.t531 VDD.t530 pfet_03v3 ad=2.08p pd=8.52u as=2.08p ps=8.52u w=8u l=0.28u
X4 VSS.t15 a_2700_41600.t13 O_CAPTURE_CLKB.t0 VSS.t14 nfet_03v3 ad=2.08p pd=8.52u as=2.08p ps=8.52u w=8u l=0.28u
X5 VSS.t117 a_17292_41600.t53 a_21324_41600.t28 VSS.t116 nfet_03v3 ad=2.08p pd=8.52u as=2.08p ps=8.52u w=8u l=0.28u
X6 VDD.t193 a_14540_41600.t35 a_17292_41600.t23 VDD.t192 pfet_03v3 ad=2.08p pd=8.52u as=2.08p ps=8.52u w=8u l=0.28u
X7 O_SENSE.t3 a_21324_41600.t140 VDD.t13 VDD.t12 pfet_03v3 ad=2.08p pd=8.52u as=2.08p ps=8.52u w=8u l=0.28u
X8 VSS.t141 a_21324_41600.t111 O_SENSE.t60 VSS.t140 nfet_03v3 ad=2.08p pd=8.52u as=2.08p ps=8.52u w=8u l=0.28u
X9 VDD.t259 a_2700_6400.t17 E_CAPTURE_CLKB.t11 VDD.t258 pfet_03v3 ad=2.08p pd=8.52u as=2.08p ps=8.52u w=8u l=0.28u
X10 a_21324_6400.t48 a_17292_6400.t42 VSS.t381 VSS.t380 nfet_03v3 ad=2.08p pd=8.52u as=2.08p ps=8.52u w=8u l=0.28u
X11 a_21324_41600.t11 a_17292_41600.t40 VSS.t53 VSS.t52 nfet_03v3 ad=2.08p pd=8.52u as=2.08p ps=8.52u w=8u l=0.28u
X12 VDD.t547 a_2700_41600.t19 O_CAPTURE_CLKB.t13 VDD.t546 pfet_03v3 ad=2.08p pd=8.52u as=2.08p ps=8.52u w=8u l=0.28u
X13 VDD.t101 a_17292_41600.t83 a_21324_41600.t18 VDD.t100 pfet_03v3 ad=2.08p pd=8.52u as=2.08p ps=8.52u w=8u l=0.28u
X14 VDD.t387 a_21324_41600.t173 O_SENSE.t90 VDD.t386 pfet_03v3 ad=2.08p pd=8.52u as=2.08p ps=8.52u w=8u l=0.28u
X15 VSS.t3 a_21324_41600.t123 O_SENSE.t6 VSS.t2 nfet_03v3 ad=2.08p pd=8.52u as=2.08p ps=8.52u w=8u l=0.28u
X16 E_SENSE.t78 a_21324_6400.t106 VSS.t421 VSS.t420 nfet_03v3 ad=2.08p pd=8.52u as=2.08p ps=8.52u w=8u l=0.28u
X17 VDD.t439 a_21324_6400.t173 E_SENSE.t36 VDD.t438 pfet_03v3 ad=2.08p pd=8.52u as=2.08p ps=8.52u w=8u l=0.28u
X18 a_21324_6400.t42 a_17292_6400.t40 VSS.t369 VSS.t368 nfet_03v3 ad=2.08p pd=8.52u as=2.08p ps=8.52u w=8u l=0.28u
X19 VDD.t405 a_21324_6400.t151 E_SENSE.t19 VDD.t404 pfet_03v3 ad=2.08p pd=8.52u as=2.08p ps=8.52u w=8u l=0.28u
X20 VSS.t301 a_21324_41600.t75 O_SENSE.t83 VSS.t300 nfet_03v3 ad=2.08p pd=8.52u as=2.08p ps=8.52u w=8u l=0.28u
X21 VSS.t337 CLKP_HB.t1 a_6924_6400.t2 VSS.t336 nfet_03v3 ad=2.08p pd=8.52u as=2.08p ps=8.52u w=8u l=0.28u
X22 a_14540_6400.t7 a_6924_6400.t16 VDD.t297 VDD.t296 pfet_03v3 ad=3.52p pd=16.88u as=2.08p ps=8.52u w=8u l=0.28u
X23 VDD.t283 a_21324_41600.t185 O_SENSE.t85 VDD.t282 pfet_03v3 ad=2.08p pd=8.52u as=2.08p ps=8.52u w=8u l=0.28u
X24 O_CAPTURE_CLKB.t3 a_2700_41600.t10 VSS.t27 VSS.t26 nfet_03v3 ad=2.08p pd=8.52u as=2.08p ps=8.52u w=8u l=0.28u
X25 VDD.t143 a_21324_41600.t137 O_SENSE.t40 VDD.t142 pfet_03v3 ad=2.08p pd=8.52u as=2.08p ps=8.52u w=8u l=0.28u
X26 a_6924_6400.t5 CLKP_HB.t10 VDD.t275 VDD.t274 pfet_03v3 ad=2.08p pd=8.52u as=2.08p ps=8.52u w=8u l=0.28u
X27 E_SENSE.t110 a_21324_6400.t78 VSS.t485 VSS.t484 nfet_03v3 ad=2.08p pd=8.52u as=2.08p ps=8.52u w=8u l=0.28u
X28 VSS.t577 a_4812_6400.t15 E_CAPTURE_CLK.t12 VSS.t576 nfet_03v3 ad=2.08p pd=8.52u as=3.52p ps=16.88u w=8u l=0.28u
X29 VSS.t115 a_14540_41600.t27 a_17292_41600.t15 VSS.t114 nfet_03v3 ad=2.08p pd=8.52u as=2.08p ps=8.52u w=8u l=0.28u
X30 VDD.t509 a_21324_41600.t159 O_SENSE.t106 VDD.t508 pfet_03v3 ad=2.08p pd=8.52u as=2.08p ps=8.52u w=8u l=0.28u
X31 VSS.t589 a_17292_41600.t37 a_21324_41600.t62 VSS.t588 nfet_03v3 ad=2.08p pd=8.52u as=2.08p ps=8.52u w=8u l=0.28u
X32 a_21324_41600.t32 a_17292_41600.t80 VDD.t183 VDD.t182 pfet_03v3 ad=2.08p pd=8.52u as=2.08p ps=8.52u w=8u l=0.28u
X33 VSS.t383 a_17292_6400.t43 a_21324_6400.t49 VSS.t382 nfet_03v3 ad=2.08p pd=8.52u as=2.08p ps=8.52u w=8u l=0.28u
X34 VSS.t29 a_14540_6400.t25 a_17292_6400.t0 VSS.t28 nfet_03v3 ad=2.08p pd=8.52u as=2.08p ps=8.52u w=8u l=0.28u
X35 a_17292_6400.t6 a_14540_6400.t44 VDD.t111 VDD.t110 pfet_03v3 ad=2.08p pd=8.52u as=2.08p ps=8.52u w=8u l=0.28u
X36 VSS.t319 a_17292_41600.t59 a_21324_41600.t47 VSS.t318 nfet_03v3 ad=2.08p pd=8.52u as=2.08p ps=8.52u w=8u l=0.28u
X37 E_SENSE.t108 a_21324_6400.t76 VSS.t481 VSS.t480 nfet_03v3 ad=2.08p pd=8.52u as=2.08p ps=8.52u w=8u l=0.28u
X38 VSS.t1 a_4812_6400.t13 E_CAPTURE_CLK.t1 VSS.t0 nfet_03v3 ad=2.08p pd=8.52u as=2.08p ps=8.52u w=8u l=0.28u
X39 VDD.t425 a_21324_6400.t143 E_SENSE.t29 VDD.t424 pfet_03v3 ad=2.08p pd=8.52u as=2.08p ps=8.52u w=8u l=0.28u
X40 VDD.t95 a_14540_41600.t41 a_17292_41600.t7 VDD.t94 pfet_03v3 ad=2.08p pd=8.52u as=2.08p ps=8.52u w=8u l=0.28u
X41 VSS.t403 a_21324_6400.t115 E_SENSE.t69 VSS.t402 nfet_03v3 ad=2.08p pd=8.52u as=2.08p ps=8.52u w=8u l=0.28u
X42 O_SENSE.t113 a_21324_41600.t72 VSS.t527 VSS.t526 nfet_03v3 ad=2.08p pd=8.52u as=2.08p ps=8.52u w=8u l=0.28u
X43 VDD.t91 a_17292_41600.t67 a_21324_41600.t17 VDD.t90 pfet_03v3 ad=2.08p pd=8.52u as=2.08p ps=8.52u w=8u l=0.28u
X44 VSS.t423 a_21324_6400.t107 E_SENSE.t79 VSS.t422 nfet_03v3 ad=2.08p pd=8.52u as=2.08p ps=8.52u w=8u l=0.28u
X45 E_SENSE.t52 a_21324_6400.t174 VDD.t471 VDD.t470 pfet_03v3 ad=2.08p pd=8.52u as=2.08p ps=8.52u w=8u l=0.28u
X46 a_21324_6400.t39 a_17292_6400.t76 VDD.t373 VDD.t372 pfet_03v3 ad=2.08p pd=8.52u as=2.08p ps=8.52u w=8u l=0.28u
X47 a_17292_6400.t27 a_14540_6400.t42 VDD.t577 VDD.t576 pfet_03v3 ad=2.08p pd=8.52u as=2.08p ps=8.52u w=8u l=0.28u
X48 VDD.t583 a_17292_41600.t89 a_21324_41600.t60 VDD.t582 pfet_03v3 ad=2.08p pd=8.52u as=2.08p ps=8.52u w=8u l=0.28u
X49 E_SENSE.t8 a_21324_6400.t180 VDD.t349 VDD.t348 pfet_03v3 ad=2.08p pd=8.52u as=2.08p ps=8.52u w=8u l=0.28u
X50 E_SENSE.t35 a_21324_6400.t172 VDD.t437 VDD.t436 pfet_03v3 ad=2.08p pd=8.52u as=2.08p ps=8.52u w=8u l=0.28u
X51 a_17292_41600.t18 a_14540_41600.t24 VSS.t195 VSS.t194 nfet_03v3 ad=2.08p pd=8.52u as=2.08p ps=8.52u w=8u l=0.28u
X52 VSS.t241 a_21324_41600.t81 O_SENSE.t72 VSS.t240 nfet_03v3 ad=2.08p pd=8.52u as=2.08p ps=8.52u w=8u l=0.28u
X53 O_SENSE.t97 a_21324_41600.t156 VDD.t401 VDD.t400 pfet_03v3 ad=2.08p pd=8.52u as=2.08p ps=8.52u w=8u l=0.28u
X54 VSS.t375 a_17292_6400.t35 a_21324_6400.t45 VSS.t374 nfet_03v3 ad=2.08p pd=8.52u as=2.08p ps=8.52u w=8u l=0.28u
X55 VDD.t273 CLKP_HB.t11 a_6924_6400.t4 VDD.t272 pfet_03v3 ad=2.08p pd=8.52u as=3.52p ps=16.88u w=8u l=0.28u
X56 E_CAPTURE_CLKB.t10 a_2700_6400.t14 VSS.t295 VSS.t294 nfet_03v3 ad=2.08p pd=8.52u as=2.08p ps=8.52u w=8u l=0.28u
X57 a_21324_41600.t3 a_17292_41600.t56 VSS.t19 VSS.t18 nfet_03v3 ad=2.08p pd=8.52u as=2.08p ps=8.52u w=8u l=0.28u
X58 a_17292_41600.t4 a_14540_41600.t38 VDD.t79 VDD.t78 pfet_03v3 ad=2.08p pd=8.52u as=2.08p ps=8.52u w=8u l=0.28u
X59 VDD.t161 a_21324_41600.t143 O_SENSE.t52 VDD.t160 pfet_03v3 ad=2.08p pd=8.52u as=2.08p ps=8.52u w=8u l=0.28u
X60 VSS.t443 a_21324_6400.t99 E_SENSE.t89 VSS.t442 nfet_03v3 ad=2.08p pd=8.52u as=2.08p ps=8.52u w=8u l=0.28u
X61 VSS.t483 a_21324_6400.t77 E_SENSE.t109 VSS.t482 nfet_03v3 ad=2.08p pd=8.52u as=2.08p ps=8.52u w=8u l=0.28u
X62 E_CAPTURE_CLK.t7 a_4812_6400.t14 VSS.t167 VSS.t166 nfet_03v3 ad=2.08p pd=8.52u as=2.08p ps=8.52u w=8u l=0.28u
X63 E_SENSE.t24 a_21324_6400.t144 VDD.t415 VDD.t414 pfet_03v3 ad=2.08p pd=8.52u as=2.08p ps=8.52u w=8u l=0.28u
X64 VDD.t113 a_14540_6400.t45 a_17292_6400.t7 VDD.t112 pfet_03v3 ad=2.08p pd=8.52u as=2.08p ps=8.52u w=8u l=0.28u
X65 VDD.t571 a_21324_41600.t165 O_SENSE.t126 VDD.t570 pfet_03v3 ad=2.08p pd=8.52u as=2.08p ps=8.52u w=8u l=0.28u
X66 a_21324_41600.t7 a_17292_41600.t86 VDD.t55 VDD.t54 pfet_03v3 ad=2.08p pd=8.52u as=2.08p ps=8.52u w=8u l=0.28u
X67 VDD.t579 a_14540_6400.t43 a_17292_6400.t28 VDD.t578 pfet_03v3 ad=2.08p pd=8.52u as=2.08p ps=8.52u w=8u l=0.28u
X68 VDD.t279 a_14540_41600.t47 a_17292_41600.t31 VDD.t278 pfet_03v3 ad=2.08p pd=8.52u as=3.52p ps=16.88u w=8u l=0.28u
X69 VDD.t351 a_21324_6400.t181 E_SENSE.t9 VDD.t350 pfet_03v3 ad=2.08p pd=8.52u as=2.08p ps=8.52u w=8u l=0.28u
X70 O_SENSE.t69 a_21324_41600.t78 VSS.t185 VSS.t184 nfet_03v3 ad=2.08p pd=8.52u as=2.08p ps=8.52u w=8u l=0.28u
X71 E_CAPTURE_CLK.t13 a_4812_6400.t8 VSS.t579 VSS.t578 nfet_03v3 ad=3.52p pd=16.88u as=2.08p ps=8.52u w=8u l=0.28u
X72 VSS.t495 a_21324_6400.t71 E_SENSE.t115 VSS.t494 nfet_03v3 ad=2.08p pd=8.52u as=2.08p ps=8.52u w=8u l=0.28u
X73 a_14540_41600.t10 a_6924_41600.t12 VSS.t245 VSS.t244 nfet_03v3 ad=2.08p pd=8.52u as=2.08p ps=8.52u w=8u l=0.28u
X74 O_SENSE.t65 a_21324_41600.t100 VSS.t177 VSS.t176 nfet_03v3 ad=2.08p pd=8.52u as=2.08p ps=8.52u w=8u l=0.28u
X75 a_21324_6400.t46 a_17292_6400.t36 VSS.t377 VSS.t376 nfet_03v3 ad=2.08p pd=8.52u as=2.08p ps=8.52u w=8u l=0.28u
X76 a_17292_6400.t14 a_14540_6400.t18 VSS.t153 VSS.t152 nfet_03v3 ad=2.08p pd=8.52u as=2.08p ps=8.52u w=8u l=0.28u
X77 VSS.t59 a_2700_6400.t15 E_CAPTURE_CLKB.t1 VSS.t58 nfet_03v3 ad=2.08p pd=8.52u as=3.52p ps=16.88u w=8u l=0.28u
X78 VDD.t527 a_14540_6400.t37 a_17292_6400.t23 VDD.t526 pfet_03v3 ad=2.08p pd=8.52u as=2.08p ps=8.52u w=8u l=0.28u
X79 VSS.t503 a_21324_6400.t69 E_SENSE.t119 VSS.t502 nfet_03v3 ad=2.08p pd=8.52u as=2.08p ps=8.52u w=8u l=0.28u
X80 a_17292_41600.t12 a_14540_41600.t30 VSS.t109 VSS.t108 nfet_03v3 ad=2.08p pd=8.52u as=2.08p ps=8.52u w=8u l=0.28u
X81 a_14540_41600.t4 a_6924_41600.t18 VDD.t119 VDD.t118 pfet_03v3 ad=2.08p pd=8.52u as=2.08p ps=8.52u w=8u l=0.28u
X82 O_SENSE.t93 a_21324_41600.t162 VDD.t393 VDD.t392 pfet_03v3 ad=2.08p pd=8.52u as=2.08p ps=8.52u w=8u l=0.28u
X83 E_SENSE.t84 a_21324_6400.t100 VSS.t433 VSS.t432 nfet_03v3 ad=2.08p pd=8.52u as=2.08p ps=8.52u w=8u l=0.28u
X84 VDD.t385 a_21324_6400.t167 E_SENSE.t17 VDD.t384 pfet_03v3 ad=2.08p pd=8.52u as=2.08p ps=8.52u w=8u l=0.28u
X85 O_CAPTURE_CLKB.t5 a_2700_41600.t16 VDD.t75 VDD.t74 pfet_03v3 ad=3.52p pd=16.88u as=2.08p ps=8.52u w=8u l=0.28u
X86 a_21324_6400.t44 a_17292_6400.t34 VSS.t373 VSS.t372 nfet_03v3 ad=2.08p pd=8.52u as=2.08p ps=8.52u w=8u l=0.28u
X87 VDD.t337 a_17292_6400.t69 a_21324_6400.t22 VDD.t336 pfet_03v3 ad=2.08p pd=8.52u as=2.08p ps=8.52u w=8u l=0.28u
X88 a_21324_41600.t35 a_17292_41600.t62 VSS.t207 VSS.t206 nfet_03v3 ad=2.08p pd=8.52u as=2.08p ps=8.52u w=8u l=0.28u
X89 a_17292_41600.t20 a_14540_41600.t44 VDD.t185 VDD.t184 pfet_03v3 ad=2.08p pd=8.52u as=2.08p ps=8.52u w=8u l=0.28u
X90 O_CAPTURE_CLK.t8 a_4812_41600.t14 VSS.t193 VSS.t192 nfet_03v3 ad=2.08p pd=8.52u as=2.08p ps=8.52u w=8u l=0.28u
X91 VDD.t543 a_21324_6400.t165 E_SENSE.t127 VDD.t542 pfet_03v3 ad=2.08p pd=8.52u as=2.08p ps=8.52u w=8u l=0.28u
X92 VSS.t237 a_21324_41600.t97 O_SENSE.t70 VSS.t236 nfet_03v3 ad=2.08p pd=8.52u as=2.08p ps=8.52u w=8u l=0.28u
X93 E_SENSE.t116 a_21324_6400.t72 VSS.t497 VSS.t496 nfet_03v3 ad=2.08p pd=8.52u as=2.08p ps=8.52u w=8u l=0.28u
X94 VSS.t581 a_4812_6400.t9 E_CAPTURE_CLK.t14 VSS.t580 nfet_03v3 ad=2.08p pd=8.52u as=2.08p ps=8.52u w=8u l=0.28u
X95 a_21324_41600.t6 a_17292_41600.t92 VDD.t53 VDD.t52 pfet_03v3 ad=2.08p pd=8.52u as=2.08p ps=8.52u w=8u l=0.28u
X96 O_CAPTURE_CLK.t6 a_4812_41600.t20 VDD.t99 VDD.t98 pfet_03v3 ad=2.08p pd=8.52u as=2.08p ps=8.52u w=8u l=0.28u
X97 VSS.t309 a_14540_6400.t19 a_17292_6400.t17 VSS.t308 nfet_03v3 ad=2.08p pd=8.52u as=2.08p ps=8.52u w=8u l=0.28u
X98 a_17292_6400.t20 a_14540_6400.t38 VDD.t255 VDD.t254 pfet_03v3 ad=2.08p pd=8.52u as=2.08p ps=8.52u w=8u l=0.28u
X99 O_SENSE.t121 a_21324_41600.t84 VSS.t531 VSS.t530 nfet_03v3 ad=2.08p pd=8.52u as=2.08p ps=8.52u w=8u l=0.28u
X100 VDD.t505 a_21324_41600.t183 O_SENSE.t104 VDD.t504 pfet_03v3 ad=2.08p pd=8.52u as=2.08p ps=8.52u w=8u l=0.28u
X101 E_SENSE.t114 a_21324_6400.t70 VSS.t493 VSS.t492 nfet_03v3 ad=2.08p pd=8.52u as=2.08p ps=8.52u w=8u l=0.28u
X102 VDD.t433 a_21324_6400.t137 E_SENSE.t33 VDD.t432 pfet_03v3 ad=2.08p pd=8.52u as=2.08p ps=8.52u w=8u l=0.28u
X103 E_CAPTURE_CLK.t11 a_4812_6400.t18 VDD.t519 VDD.t518 pfet_03v3 ad=2.08p pd=8.52u as=2.08p ps=8.52u w=8u l=0.28u
X104 O_SENSE.t111 a_21324_41600.t106 VSS.t523 VSS.t522 nfet_03v3 ad=2.08p pd=8.52u as=2.08p ps=8.52u w=8u l=0.28u
X105 a_4812_41600.t1 CLKN_H.t2 VSS.t161 VSS.t160 nfet_03v3 ad=2.08p pd=8.52u as=2.08p ps=8.52u w=8u l=0.28u
X106 VSS.t359 a_17292_6400.t57 a_21324_6400.t28 VSS.t358 nfet_03v3 ad=2.08p pd=8.52u as=2.08p ps=8.52u w=8u l=0.28u
X107 a_21324_6400.t23 a_17292_6400.t70 VDD.t339 VDD.t338 pfet_03v3 ad=2.08p pd=8.52u as=2.08p ps=8.52u w=8u l=0.28u
X108 a_21324_6400.t35 a_17292_6400.t92 VDD.t365 VDD.t364 pfet_03v3 ad=2.08p pd=8.52u as=2.08p ps=8.52u w=8u l=0.28u
X109 a_17292_6400.t22 a_14540_6400.t36 VDD.t525 VDD.t524 pfet_03v3 ad=2.08p pd=8.52u as=2.08p ps=8.52u w=8u l=0.28u
X110 VSS.t305 a_4812_41600.t11 O_CAPTURE_CLK.t13 VSS.t304 nfet_03v3 ad=2.08p pd=8.52u as=2.08p ps=8.52u w=8u l=0.28u
X111 a_21324_41600.t38 a_17292_41600.t78 VDD.t199 VDD.t198 pfet_03v3 ad=2.08p pd=8.52u as=2.08p ps=8.52u w=8u l=0.28u
X112 E_CAPTURE_CLKB.t13 a_2700_6400.t10 VSS.t551 VSS.t550 nfet_03v3 ad=2.08p pd=8.52u as=2.08p ps=8.52u w=8u l=0.28u
X113 O_SENSE.t27 a_21324_41600.t118 VSS.t67 VSS.t66 nfet_03v3 ad=2.08p pd=8.52u as=2.08p ps=8.52u w=8u l=0.28u
X114 O_SENSE.t95 a_21324_41600.t168 VDD.t397 VDD.t396 pfet_03v3 ad=2.08p pd=8.52u as=2.08p ps=8.52u w=8u l=0.28u
X115 E_SENSE.t16 a_21324_6400.t166 VDD.t383 VDD.t382 pfet_03v3 ad=2.08p pd=8.52u as=2.08p ps=8.52u w=8u l=0.28u
X116 a_4812_41600.t7 CLKN_H.t4 VDD.t177 VDD.t176 pfet_03v3 ad=3.52p pd=16.88u as=2.08p ps=8.52u w=8u l=0.28u
X117 VDD.t83 a_4812_41600.t17 O_CAPTURE_CLK.t3 VDD.t82 pfet_03v3 ad=2.08p pd=8.52u as=2.08p ps=8.52u w=8u l=0.28u
X118 VSS.t265 CLKN_HB.t5 a_2700_41600.t2 VSS.t264 nfet_03v3 ad=2.08p pd=8.52u as=2.08p ps=8.52u w=8u l=0.28u
X119 O_SENSE.t17 a_21324_41600.t70 VSS.t47 VSS.t46 nfet_03v3 ad=2.08p pd=8.52u as=2.08p ps=8.52u w=8u l=0.28u
X120 VDD.t77 a_2700_6400.t19 E_CAPTURE_CLKB.t2 VDD.t76 pfet_03v3 ad=2.08p pd=8.52u as=2.08p ps=8.52u w=8u l=0.28u
X121 O_SENSE.t89 a_21324_41600.t180 VDD.t291 VDD.t290 pfet_03v3 ad=2.08p pd=8.52u as=2.08p ps=8.52u w=8u l=0.28u
X122 a_6924_41600.t1 CLKN_HB.t2 VSS.t271 VSS.t270 nfet_03v3 ad=2.08p pd=8.52u as=2.08p ps=8.52u w=8u l=0.28u
X123 a_2700_6400.t1 CLKP_HB.t6 VSS.t329 VSS.t328 nfet_03v3 ad=2.08p pd=8.52u as=2.08p ps=8.52u w=8u l=0.28u
X124 VSS.t535 a_6924_41600.t15 a_14540_41600.t15 VSS.t534 nfet_03v3 ad=2.08p pd=8.52u as=3.52p ps=16.88u w=8u l=0.28u
X125 VSS.t455 a_21324_6400.t93 E_SENSE.t95 VSS.t454 nfet_03v3 ad=2.08p pd=8.52u as=2.08p ps=8.52u w=8u l=0.28u
X126 E_SENSE.t4 a_21324_6400.t160 VDD.t315 VDD.t314 pfet_03v3 ad=2.08p pd=8.52u as=2.08p ps=8.52u w=8u l=0.28u
X127 VDD.t115 a_4812_6400.t19 E_CAPTURE_CLK.t5 VDD.t114 pfet_03v3 ad=2.08p pd=8.52u as=2.08p ps=8.52u w=8u l=0.28u
X128 VSS.t37 a_21324_41600.t103 O_SENSE.t12 VSS.t36 nfet_03v3 ad=2.08p pd=8.52u as=2.08p ps=8.52u w=8u l=0.28u
X129 O_SENSE.t5 a_21324_41600.t132 VDD.t17 VDD.t16 pfet_03v3 ad=2.08p pd=8.52u as=2.08p ps=8.52u w=8u l=0.28u
X130 a_14540_6400.t10 a_6924_6400.t14 VSS.t563 VSS.t562 nfet_03v3 ad=2.08p pd=8.52u as=2.08p ps=8.52u w=8u l=0.28u
X131 a_6924_41600.t7 CLKN_HB.t8 VDD.t209 VDD.t208 pfet_03v3 ad=3.52p pd=16.88u as=2.08p ps=8.52u w=8u l=0.28u
X132 a_21324_6400.t29 a_17292_6400.t58 VSS.t361 VSS.t360 nfet_03v3 ad=2.08p pd=8.52u as=2.08p ps=8.52u w=8u l=0.28u
X133 a_2700_6400.t3 CLKP_HB.t4 VSS.t335 VSS.t334 nfet_03v3 ad=3.52p pd=16.88u as=2.08p ps=8.52u w=8u l=0.28u
X134 VDD.t359 a_17292_6400.t93 a_21324_6400.t32 VDD.t358 pfet_03v3 ad=2.08p pd=8.52u as=2.08p ps=8.52u w=8u l=0.28u
X135 VDD.t263 CLKP_HB.t15 a_2700_6400.t4 VDD.t262 pfet_03v3 ad=2.08p pd=8.52u as=3.52p ps=16.88u w=8u l=0.28u
X136 VDD.t49 a_6924_41600.t21 a_14540_41600.t3 VDD.t48 pfet_03v3 ad=2.08p pd=8.52u as=2.08p ps=8.52u w=8u l=0.28u
X137 a_21324_41600.t59 a_17292_41600.t32 VSS.t583 VSS.t582 nfet_03v3 ad=3.52p pd=16.88u as=2.08p ps=8.52u w=8u l=0.28u
X138 VDD.t237 a_17292_41600.t75 a_21324_41600.t42 VDD.t236 pfet_03v3 ad=2.08p pd=8.52u as=2.08p ps=8.52u w=8u l=0.28u
X139 E_SENSE.t2 a_21324_6400.t158 VDD.t307 VDD.t306 pfet_03v3 ad=2.08p pd=8.52u as=2.08p ps=8.52u w=8u l=0.28u
X140 VSS.t7 a_21324_41600.t115 O_SENSE.t8 VSS.t6 nfet_03v3 ad=2.08p pd=8.52u as=2.08p ps=8.52u w=8u l=0.28u
X141 O_CAPTURE_CLKB.t1 a_2700_41600.t14 VSS.t17 VSS.t16 nfet_03v3 ad=2.08p pd=8.52u as=2.08p ps=8.52u w=8u l=0.28u
X142 a_17292_41600.t2 a_14540_41600.t36 VDD.t43 VDD.t42 pfet_03v3 ad=2.08p pd=8.52u as=2.08p ps=8.52u w=8u l=0.28u
X143 VSS.t507 a_21324_6400.t65 E_SENSE.t121 VSS.t506 nfet_03v3 ad=2.08p pd=8.52u as=2.08p ps=8.52u w=8u l=0.28u
X144 VDD.t363 a_17292_6400.t91 a_21324_6400.t34 VDD.t362 pfet_03v3 ad=2.08p pd=8.52u as=2.08p ps=8.52u w=8u l=0.28u
X145 VSS.t91 a_21324_41600.t67 O_SENSE.t34 VSS.t90 nfet_03v3 ad=2.08p pd=8.52u as=2.08p ps=8.52u w=8u l=0.28u
X146 a_21324_41600.t52 a_17292_41600.t84 VDD.t521 VDD.t520 pfet_03v3 ad=2.08p pd=8.52u as=2.08p ps=8.52u w=8u l=0.28u
X147 a_4812_6400.t3 CLKP_H.t0 VSS.t279 VSS.t278 nfet_03v3 ad=3.52p pd=16.88u as=2.08p ps=8.52u w=8u l=0.28u
X148 E_SENSE.t57 a_21324_6400.t130 VDD.t481 VDD.t480 pfet_03v3 ad=2.08p pd=8.52u as=2.08p ps=8.52u w=8u l=0.28u
X149 E_CAPTURE_CLKB.t9 a_2700_6400.t20 VDD.t247 VDD.t246 pfet_03v3 ad=2.08p pd=8.52u as=2.08p ps=8.52u w=8u l=0.28u
X150 O_SENSE.t7 a_21324_41600.t124 VSS.t5 VSS.t4 nfet_03v3 ad=2.08p pd=8.52u as=2.08p ps=8.52u w=8u l=0.28u
X151 VDD.t147 a_21324_41600.t129 O_SENSE.t42 VDD.t146 pfet_03v3 ad=2.08p pd=8.52u as=2.08p ps=8.52u w=8u l=0.28u
X152 VSS.t343 a_14540_41600.t19 a_17292_41600.t25 VSS.t342 nfet_03v3 ad=2.08p pd=8.52u as=2.08p ps=8.52u w=8u l=0.28u
X153 a_21324_6400.t3 a_17292_6400.t50 VSS.t221 VSS.t220 nfet_03v3 ad=2.08p pd=8.52u as=2.08p ps=8.52u w=8u l=0.28u
X154 VDD.t317 a_21324_6400.t161 E_SENSE.t5 VDD.t316 pfet_03v3 ad=2.08p pd=8.52u as=2.08p ps=8.52u w=8u l=0.28u
X155 VDD.t27 a_4812_41600.t23 O_CAPTURE_CLK.t0 VDD.t26 pfet_03v3 ad=2.08p pd=8.52u as=3.52p ps=16.88u w=8u l=0.28u
X156 O_SENSE.t84 a_21324_41600.t76 VSS.t303 VSS.t302 nfet_03v3 ad=2.08p pd=8.52u as=2.08p ps=8.52u w=8u l=0.28u
X157 VDD.t157 a_21324_41600.t151 O_SENSE.t50 VDD.t156 pfet_03v3 ad=2.08p pd=8.52u as=2.08p ps=8.52u w=8u l=0.28u
X158 VSS.t357 a_6924_6400.t15 a_14540_6400.t6 VSS.t356 nfet_03v3 ad=2.08p pd=8.52u as=3.52p ps=16.88u w=8u l=0.28u
X159 E_SENSE.t61 a_21324_6400.t128 VDD.t487 VDD.t486 pfet_03v3 ad=3.52p pd=16.88u as=2.08p ps=8.52u w=8u l=0.28u
X160 VSS.t331 CLKP_HB.t5 a_2700_6400.t2 VSS.t330 nfet_03v3 ad=2.08p pd=8.52u as=2.08p ps=8.52u w=8u l=0.28u
X161 VSS.t25 a_2700_41600.t11 O_CAPTURE_CLKB.t2 VSS.t24 nfet_03v3 ad=2.08p pd=8.52u as=2.08p ps=8.52u w=8u l=0.28u
X162 E_SENSE.t74 a_21324_6400.t114 VSS.t413 VSS.t412 nfet_03v3 ad=2.08p pd=8.52u as=2.08p ps=8.52u w=8u l=0.28u
X163 VDD.t309 a_21324_6400.t159 E_SENSE.t3 VDD.t308 pfet_03v3 ad=2.08p pd=8.52u as=2.08p ps=8.52u w=8u l=0.28u
X164 VSS.t203 a_17292_41600.t51 a_21324_41600.t33 VSS.t202 nfet_03v3 ad=2.08p pd=8.52u as=2.08p ps=8.52u w=8u l=0.28u
X165 VDD.t133 a_14540_41600.t33 a_17292_41600.t9 VDD.t132 pfet_03v3 ad=2.08p pd=8.52u as=2.08p ps=8.52u w=8u l=0.28u
X166 VSS.t69 a_21324_41600.t109 O_SENSE.t28 VSS.t68 nfet_03v3 ad=2.08p pd=8.52u as=2.08p ps=8.52u w=8u l=0.28u
X167 O_SENSE.t41 a_21324_41600.t138 VDD.t145 VDD.t144 pfet_03v3 ad=2.08p pd=8.52u as=2.08p ps=8.52u w=8u l=0.28u
X168 VSS.t273 CLKP_H.t3 a_4812_6400.t0 VSS.t272 nfet_03v3 ad=2.08p pd=8.52u as=3.52p ps=16.88u w=8u l=0.28u
X169 VDD.t181 a_17292_41600.t81 a_21324_41600.t31 VDD.t180 pfet_03v3 ad=2.08p pd=8.52u as=2.08p ps=8.52u w=8u l=0.28u
X170 VSS.t121 a_21324_41600.t121 O_SENSE.t44 VSS.t120 nfet_03v3 ad=2.08p pd=8.52u as=2.08p ps=8.52u w=8u l=0.28u
X171 E_SENSE.t100 a_21324_6400.t86 VSS.t465 VSS.t464 nfet_03v3 ad=2.08p pd=8.52u as=2.08p ps=8.52u w=8u l=0.28u
X172 VSS.t277 CLKP_H.t1 a_4812_6400.t2 VSS.t276 nfet_03v3 ad=2.08p pd=8.52u as=2.08p ps=8.52u w=8u l=0.28u
X173 VDD.t483 a_21324_6400.t131 E_SENSE.t58 VDD.t482 pfet_03v3 ad=2.08p pd=8.52u as=2.08p ps=8.52u w=8u l=0.28u
X174 a_17292_41600.t0 a_14540_41600.t42 VDD.t3 VDD.t2 pfet_03v3 ad=2.08p pd=8.52u as=2.08p ps=8.52u w=8u l=0.28u
X175 VSS.t145 a_21324_41600.t73 O_SENSE.t62 VSS.t144 nfet_03v3 ad=2.08p pd=8.52u as=2.08p ps=8.52u w=8u l=0.28u
X176 VSS.t223 a_17292_6400.t51 a_21324_6400.t4 VSS.t222 nfet_03v3 ad=2.08p pd=8.52u as=2.08p ps=8.52u w=8u l=0.28u
X177 a_21324_6400.t12 a_17292_6400.t86 VDD.t305 VDD.t304 pfet_03v3 ad=2.08p pd=8.52u as=2.08p ps=8.52u w=8u l=0.28u
X178 VSS.t281 a_21324_41600.t95 O_SENSE.t76 VSS.t280 nfet_03v3 ad=2.08p pd=8.52u as=2.08p ps=8.52u w=8u l=0.28u
X179 a_4812_6400.t5 CLKP_H.t6 VDD.t227 VDD.t226 pfet_03v3 ad=2.08p pd=8.52u as=2.08p ps=8.52u w=8u l=0.28u
X180 a_21324_41600.t24 a_17292_41600.t48 VSS.t97 VSS.t96 nfet_03v3 ad=2.08p pd=8.52u as=2.08p ps=8.52u w=8u l=0.28u
X181 VSS.t515 a_21324_6400.t123 E_SENSE.t125 VSS.t514 nfet_03v3 ad=2.08p pd=8.52u as=2.08p ps=8.52u w=8u l=0.28u
X182 a_2700_41600.t5 CLKN_HB.t14 VDD.t217 VDD.t216 pfet_03v3 ad=2.08p pd=8.52u as=2.08p ps=8.52u w=8u l=0.28u
X183 VDD.t165 a_21324_41600.t135 O_SENSE.t54 VDD.t164 pfet_03v3 ad=2.08p pd=8.52u as=2.08p ps=8.52u w=8u l=0.28u
X184 VSS.t197 a_14540_41600.t25 a_17292_41600.t19 VSS.t196 nfet_03v3 ad=2.08p pd=8.52u as=2.08p ps=8.52u w=8u l=0.28u
X185 a_21324_6400.t16 a_17292_6400.t84 VDD.t321 VDD.t320 pfet_03v3 ad=2.08p pd=8.52u as=2.08p ps=8.52u w=8u l=0.28u
X186 VSS.t353 a_17292_41600.t35 a_21324_41600.t49 VSS.t352 nfet_03v3 ad=2.08p pd=8.52u as=2.08p ps=8.52u w=8u l=0.28u
X187 VDD.t501 a_21324_41600.t157 O_SENSE.t102 VDD.t500 pfet_03v3 ad=2.08p pd=8.52u as=2.08p ps=8.52u w=8u l=0.28u
X188 VSS.t155 a_2700_6400.t9 E_CAPTURE_CLKB.t5 VSS.t154 nfet_03v3 ad=2.08p pd=8.52u as=2.08p ps=8.52u w=8u l=0.28u
X189 E_SENSE.t42 a_21324_6400.t188 VDD.t451 VDD.t450 pfet_03v3 ad=2.08p pd=8.52u as=2.08p ps=8.52u w=8u l=0.28u
X190 VSS.t553 a_17292_41600.t57 a_21324_41600.t58 VSS.t552 nfet_03v3 ad=2.08p pd=8.52u as=2.08p ps=8.52u w=8u l=0.28u
X191 VDD.t81 a_14540_41600.t39 a_17292_41600.t5 VDD.t80 pfet_03v3 ad=2.08p pd=8.52u as=2.08p ps=8.52u w=8u l=0.28u
X192 VSS.t415 a_21324_6400.t109 E_SENSE.t75 VSS.t414 nfet_03v3 ad=2.08p pd=8.52u as=2.08p ps=8.52u w=8u l=0.28u
X193 VSS.t467 a_21324_6400.t87 E_SENSE.t101 VSS.t466 nfet_03v3 ad=2.08p pd=8.52u as=2.08p ps=8.52u w=8u l=0.28u
X194 E_SENSE.t10 a_21324_6400.t154 VDD.t353 VDD.t352 pfet_03v3 ad=2.08p pd=8.52u as=2.08p ps=8.52u w=8u l=0.28u
X195 a_14540_6400.t11 a_6924_6400.t8 VSS.t565 VSS.t564 nfet_03v3 ad=3.52p pd=16.88u as=2.08p ps=8.52u w=8u l=0.28u
X196 O_SENSE.t33 a_21324_41600.t92 VSS.t89 VSS.t88 nfet_03v3 ad=2.08p pd=8.52u as=2.08p ps=8.52u w=8u l=0.28u
X197 VDD.t109 a_17292_41600.t87 a_21324_41600.t22 VDD.t108 pfet_03v3 ad=2.08p pd=8.52u as=2.08p ps=8.52u w=8u l=0.28u
X198 VDD.t287 a_21324_41600.t191 O_SENSE.t87 VDD.t286 pfet_03v3 ad=2.08p pd=8.52u as=3.52p ps=16.88u w=8u l=0.28u
X199 E_SENSE.t14 a_21324_6400.t152 VDD.t379 VDD.t378 pfet_03v3 ad=2.08p pd=8.52u as=2.08p ps=8.52u w=8u l=0.28u
X200 a_17292_41600.t28 a_14540_41600.t22 VSS.t349 VSS.t348 nfet_03v3 ad=2.08p pd=8.52u as=2.08p ps=8.52u w=8u l=0.28u
X201 VDD.t33 a_6924_6400.t17 a_14540_6400.t0 VDD.t32 pfet_03v3 ad=2.08p pd=8.52u as=2.08p ps=8.52u w=8u l=0.28u
X202 VSS.t285 a_21324_41600.t79 O_SENSE.t78 VSS.t284 nfet_03v3 ad=2.08p pd=8.52u as=2.08p ps=8.52u w=8u l=0.28u
X203 O_SENSE.t37 a_21324_41600.t154 VDD.t137 VDD.t136 pfet_03v3 ad=2.08p pd=8.52u as=2.08p ps=8.52u w=8u l=0.28u
X204 a_6924_6400.t1 CLKP_HB.t2 VSS.t325 VSS.t324 nfet_03v3 ad=2.08p pd=8.52u as=2.08p ps=8.52u w=8u l=0.28u
X205 VDD.t303 a_17292_6400.t85 a_21324_6400.t11 VDD.t302 pfet_03v3 ad=2.08p pd=8.52u as=2.08p ps=8.52u w=8u l=0.28u
X206 VSS.t83 a_21324_41600.t101 O_SENSE.t30 VSS.t82 nfet_03v3 ad=2.08p pd=8.52u as=2.08p ps=8.52u w=8u l=0.28u
X207 a_21324_41600.t29 a_17292_41600.t54 VSS.t119 VSS.t118 nfet_03v3 ad=2.08p pd=8.52u as=2.08p ps=8.52u w=8u l=0.28u
X208 O_SENSE.t117 a_21324_41600.t176 VDD.t535 VDD.t534 pfet_03v3 ad=2.08p pd=8.52u as=2.08p ps=8.52u w=8u l=0.28u
X209 VDD.t453 a_21324_6400.t189 E_SENSE.t43 VDD.t452 pfet_03v3 ad=2.08p pd=8.52u as=2.08p ps=8.52u w=8u l=0.28u
X210 a_17292_6400.t24 a_14540_6400.t28 VSS.t545 VSS.t544 nfet_03v3 ad=2.08p pd=8.52u as=2.08p ps=8.52u w=8u l=0.28u
X211 VSS.t475 a_21324_6400.t79 E_SENSE.t105 VSS.t474 nfet_03v3 ad=2.08p pd=8.52u as=2.08p ps=8.52u w=8u l=0.28u
X212 VDD.t121 a_6924_41600.t19 a_14540_41600.t5 VDD.t120 pfet_03v3 ad=2.08p pd=8.52u as=2.08p ps=8.52u w=8u l=0.28u
X213 VSS.t111 a_14540_41600.t31 a_17292_41600.t13 VSS.t110 nfet_03v3 ad=2.08p pd=8.52u as=3.52p ps=16.88u w=8u l=0.28u
X214 VDD.t537 a_21324_41600.t163 O_SENSE.t118 VDD.t536 pfet_03v3 ad=2.08p pd=8.52u as=2.08p ps=8.52u w=8u l=0.28u
X215 a_21324_6400.t50 a_17292_6400.t44 VSS.t385 VSS.t384 nfet_03v3 ad=2.08p pd=8.52u as=2.08p ps=8.52u w=8u l=0.28u
X216 E_SENSE.t76 a_21324_6400.t110 VSS.t417 VSS.t416 nfet_03v3 ad=2.08p pd=8.52u as=2.08p ps=8.52u w=8u l=0.28u
X217 VDD.t327 a_17292_6400.t79 a_21324_6400.t17 VDD.t326 pfet_03v3 ad=2.08p pd=8.52u as=2.08p ps=8.52u w=8u l=0.28u
X218 VDD.t201 a_2700_41600.t17 O_CAPTURE_CLKB.t8 VDD.t200 pfet_03v3 ad=2.08p pd=8.52u as=2.08p ps=8.52u w=8u l=0.28u
X219 a_17292_6400.t1 a_14540_6400.t26 VSS.t31 VSS.t30 nfet_03v3 ad=2.08p pd=8.52u as=2.08p ps=8.52u w=8u l=0.28u
X220 E_SENSE.t70 a_21324_6400.t116 VSS.t405 VSS.t404 nfet_03v3 ad=2.08p pd=8.52u as=2.08p ps=8.52u w=8u l=0.28u
X221 VDD.t473 a_21324_6400.t175 E_SENSE.t53 VDD.t472 pfet_03v3 ad=2.08p pd=8.52u as=2.08p ps=8.52u w=8u l=0.28u
X222 E_SENSE.t80 a_21324_6400.t108 VSS.t425 VSS.t424 nfet_03v3 ad=2.08p pd=8.52u as=2.08p ps=8.52u w=8u l=0.28u
X223 VDD.t367 a_17292_6400.t77 a_21324_6400.t36 VDD.t366 pfet_03v3 ad=2.08p pd=8.52u as=2.08p ps=8.52u w=8u l=0.28u
X224 a_14540_41600.t12 a_6924_41600.t10 VSS.t289 VSS.t288 nfet_03v3 ad=2.08p pd=8.52u as=2.08p ps=8.52u w=8u l=0.28u
X225 VSS.t327 CLKP_HB.t3 a_6924_6400.t0 VSS.t326 nfet_03v3 ad=2.08p pd=8.52u as=3.52p ps=16.88u w=8u l=0.28u
X226 a_14540_6400.t1 a_6924_6400.t18 VDD.t35 VDD.t34 pfet_03v3 ad=2.08p pd=8.52u as=2.08p ps=8.52u w=8u l=0.28u
X227 O_SENSE.t71 a_21324_41600.t98 VSS.t239 VSS.t238 nfet_03v3 ad=2.08p pd=8.52u as=2.08p ps=8.52u w=8u l=0.28u
X228 O_CAPTURE_CLKB.t12 a_2700_41600.t8 VSS.t321 VSS.t320 nfet_03v3 ad=3.52p pd=16.88u as=2.08p ps=8.52u w=8u l=0.28u
X229 VDD.t233 a_4812_41600.t21 O_CAPTURE_CLK.t11 VDD.t232 pfet_03v3 ad=2.08p pd=8.52u as=2.08p ps=8.52u w=8u l=0.28u
X230 a_14540_41600.t8 a_6924_41600.t16 VDD.t195 VDD.t194 pfet_03v3 ad=3.52p pd=16.88u as=2.08p ps=8.52u w=8u l=0.28u
X231 a_21324_41600.t39 a_17292_41600.t70 VDD.t205 VDD.t204 pfet_03v3 ad=2.08p pd=8.52u as=2.08p ps=8.52u w=8u l=0.28u
X232 a_17292_41600.t16 a_14540_41600.t28 VSS.t171 VSS.t170 nfet_03v3 ad=2.08p pd=8.52u as=2.08p ps=8.52u w=8u l=0.28u
X233 VSS.t547 a_14540_6400.t29 a_17292_6400.t25 VSS.t546 nfet_03v3 ad=2.08p pd=8.52u as=2.08p ps=8.52u w=8u l=0.28u
X234 O_SENSE.t107 a_21324_41600.t160 VDD.t511 VDD.t510 pfet_03v3 ad=2.08p pd=8.52u as=2.08p ps=8.52u w=8u l=0.28u
X235 E_SENSE.t106 a_21324_6400.t80 VSS.t477 VSS.t476 nfet_03v3 ad=2.08p pd=8.52u as=2.08p ps=8.52u w=8u l=0.28u
X236 a_21324_41600.t57 a_17292_41600.t60 VSS.t543 VSS.t542 nfet_03v3 ad=2.08p pd=8.52u as=2.08p ps=8.52u w=8u l=0.28u
X237 a_21324_6400.t18 a_17292_6400.t80 VDD.t329 VDD.t328 pfet_03v3 ad=2.08p pd=8.52u as=2.08p ps=8.52u w=8u l=0.28u
X238 O_CAPTURE_CLK.t14 a_4812_41600.t12 VSS.t307 VSS.t306 nfet_03v3 ad=2.08p pd=8.52u as=2.08p ps=8.52u w=8u l=0.28u
X239 VSS.t33 a_14540_6400.t27 a_17292_6400.t2 VSS.t32 nfet_03v3 ad=2.08p pd=8.52u as=2.08p ps=8.52u w=8u l=0.28u
X240 VDD.t417 a_21324_6400.t145 E_SENSE.t25 VDD.t416 pfet_03v3 ad=2.08p pd=8.52u as=2.08p ps=8.52u w=8u l=0.28u
X241 a_17292_6400.t15 a_14540_6400.t46 VDD.t243 VDD.t242 pfet_03v3 ad=2.08p pd=8.52u as=2.08p ps=8.52u w=8u l=0.28u
X242 VSS.t407 a_21324_6400.t117 E_SENSE.t71 VSS.t406 nfet_03v3 ad=2.08p pd=8.52u as=2.08p ps=8.52u w=8u l=0.28u
X243 E_SENSE.t50 a_21324_6400.t176 VDD.t467 VDD.t466 pfet_03v3 ad=2.08p pd=8.52u as=2.08p ps=8.52u w=8u l=0.28u
X244 VSS.t137 a_21324_41600.t119 O_SENSE.t58 VSS.t136 nfet_03v3 ad=2.08p pd=8.52u as=2.08p ps=8.52u w=8u l=0.28u
X245 a_21324_6400.t37 a_17292_6400.t78 VDD.t369 VDD.t368 pfet_03v3 ad=2.08p pd=8.52u as=2.08p ps=8.52u w=8u l=0.28u
X246 O_CAPTURE_CLK.t4 a_4812_41600.t18 VDD.t85 VDD.t84 pfet_03v3 ad=2.08p pd=8.52u as=2.08p ps=8.52u w=8u l=0.28u
X247 E_SENSE.t12 a_21324_6400.t182 VDD.t375 VDD.t374 pfet_03v3 ad=2.08p pd=8.52u as=2.08p ps=8.52u w=8u l=0.28u
X248 O_SENSE.t39 a_21324_41600.t146 VDD.t141 VDD.t140 pfet_03v3 ad=2.08p pd=8.52u as=2.08p ps=8.52u w=8u l=0.28u
X249 VSS.t313 a_14540_6400.t21 a_17292_6400.t19 VSS.t312 nfet_03v3 ad=2.08p pd=8.52u as=2.08p ps=8.52u w=8u l=0.28u
X250 a_21324_41600.t14 a_17292_41600.t46 VSS.t57 VSS.t56 nfet_03v3 ad=2.08p pd=8.52u as=2.08p ps=8.52u w=8u l=0.28u
X251 VSS.t427 a_21324_6400.t103 E_SENSE.t81 VSS.t426 nfet_03v3 ad=2.08p pd=8.52u as=2.08p ps=8.52u w=8u l=0.28u
X252 a_4812_41600.t3 CLKN_H.t0 VSS.t165 VSS.t164 nfet_03v3 ad=3.52p pd=16.88u as=2.08p ps=8.52u w=8u l=0.28u
X253 VSS.t379 a_17292_6400.t37 a_21324_6400.t47 VSS.t378 nfet_03v3 ad=2.08p pd=8.52u as=2.08p ps=8.52u w=8u l=0.28u
X254 O_SENSE.t13 a_21324_41600.t104 VSS.t39 VSS.t38 nfet_03v3 ad=2.08p pd=8.52u as=2.08p ps=8.52u w=8u l=0.28u
X255 a_2700_41600.t7 CLKN_HB.t12 VDD.t221 VDD.t220 pfet_03v3 ad=3.52p pd=16.88u as=2.08p ps=8.52u w=8u l=0.28u
X256 VDD.t71 a_21324_41600.t133 O_SENSE.t22 VDD.t70 pfet_03v3 ad=2.08p pd=8.52u as=2.08p ps=8.52u w=8u l=0.28u
X257 VSS.t199 a_4812_41600.t9 O_CAPTURE_CLK.t9 VSS.t198 nfet_03v3 ad=2.08p pd=8.52u as=2.08p ps=8.52u w=8u l=0.28u
X258 a_14540_41600.t0 a_6924_41600.t22 VDD.t19 VDD.t18 pfet_03v3 ad=2.08p pd=8.52u as=2.08p ps=8.52u w=8u l=0.28u
X259 a_21324_41600.t0 a_17292_41600.t76 VDD.t25 VDD.t24 pfet_03v3 ad=2.08p pd=8.52u as=2.08p ps=8.52u w=8u l=0.28u
X260 VSS.t435 a_21324_6400.t101 E_SENSE.t85 VSS.t434 nfet_03v3 ad=2.08p pd=8.52u as=2.08p ps=8.52u w=8u l=0.28u
X261 E_SENSE.t30 a_21324_6400.t168 VDD.t427 VDD.t426 pfet_03v3 ad=2.08p pd=8.52u as=2.08p ps=8.52u w=8u l=0.28u
X262 E_SENSE.t20 a_21324_6400.t146 VDD.t407 VDD.t406 pfet_03v3 ad=2.08p pd=8.52u as=2.08p ps=8.52u w=8u l=0.28u
X263 O_SENSE.t9 a_21324_41600.t116 VSS.t9 VSS.t8 nfet_03v3 ad=2.08p pd=8.52u as=2.08p ps=8.52u w=8u l=0.28u
X264 O_SENSE.t35 a_21324_41600.t68 VSS.t93 VSS.t92 nfet_03v3 ad=2.08p pd=8.52u as=2.08p ps=8.52u w=8u l=0.28u
X265 a_6924_41600.t3 CLKN_HB.t0 VSS.t257 VSS.t256 nfet_03v3 ad=3.52p pd=16.88u as=2.08p ps=8.52u w=8u l=0.28u
X266 VSS.t247 a_6924_41600.t13 a_14540_41600.t11 VSS.t246 nfet_03v3 ad=2.08p pd=8.52u as=2.08p ps=8.52u w=8u l=0.28u
X267 VSS.t253 a_17292_41600.t43 a_21324_41600.t40 VSS.t252 nfet_03v3 ad=2.08p pd=8.52u as=2.08p ps=8.52u w=8u l=0.28u
X268 VSS.t487 a_21324_6400.t73 E_SENSE.t111 VSS.t486 nfet_03v3 ad=2.08p pd=8.52u as=2.08p ps=8.52u w=8u l=0.28u
X269 a_17292_6400.t3 a_14540_6400.t22 VSS.t77 VSS.t76 nfet_03v3 ad=2.08p pd=8.52u as=2.08p ps=8.52u w=8u l=0.28u
X270 E_CAPTURE_CLK.t9 a_4812_6400.t10 VSS.t209 VSS.t208 nfet_03v3 ad=2.08p pd=8.52u as=2.08p ps=8.52u w=8u l=0.28u
X271 O_SENSE.t43 a_21324_41600.t130 VDD.t149 VDD.t148 pfet_03v3 ad=2.08p pd=8.52u as=2.08p ps=8.52u w=8u l=0.28u
X272 a_17292_41600.t26 a_14540_41600.t20 VSS.t345 VSS.t344 nfet_03v3 ad=2.08p pd=8.52u as=2.08p ps=8.52u w=8u l=0.28u
X273 a_21324_6400.t56 a_17292_6400.t60 VSS.t555 VSS.t554 nfet_03v3 ad=2.08p pd=8.52u as=2.08p ps=8.52u w=8u l=0.28u
X274 a_21324_6400.t40 a_17292_6400.t38 VSS.t365 VSS.t364 nfet_03v3 ad=2.08p pd=8.52u as=2.08p ps=8.52u w=8u l=0.28u
X275 a_17292_6400.t18 a_14540_6400.t20 VSS.t311 VSS.t310 nfet_03v3 ad=2.08p pd=8.52u as=2.08p ps=8.52u w=8u l=0.28u
X276 VDD.t333 a_17292_6400.t73 a_21324_6400.t20 VDD.t332 pfet_03v3 ad=2.08p pd=8.52u as=2.08p ps=8.52u w=8u l=0.28u
X277 VDD.t257 a_14540_6400.t39 a_17292_6400.t21 VDD.t256 pfet_03v3 ad=2.08p pd=8.52u as=2.08p ps=8.52u w=8u l=0.28u
X278 VDD.t523 a_17292_41600.t73 a_21324_41600.t53 VDD.t522 pfet_03v3 ad=2.08p pd=8.52u as=2.08p ps=8.52u w=8u l=0.28u
X279 O_SENSE.t51 a_21324_41600.t152 VDD.t159 VDD.t158 pfet_03v3 ad=2.08p pd=8.52u as=2.08p ps=8.52u w=8u l=0.28u
X280 E_SENSE.t34 a_21324_6400.t138 VDD.t435 VDD.t434 pfet_03v3 ad=2.08p pd=8.52u as=2.08p ps=8.52u w=8u l=0.28u
X281 a_21324_41600.t34 a_17292_41600.t52 VSS.t205 VSS.t204 nfet_03v3 ad=2.08p pd=8.52u as=2.08p ps=8.52u w=8u l=0.28u
X282 VDD.t545 a_17292_41600.t95 a_21324_41600.t54 VDD.t544 pfet_03v3 ad=2.08p pd=8.52u as=3.52p ps=16.88u w=8u l=0.28u
X283 E_SENSE.t86 a_21324_6400.t102 VSS.t437 VSS.t436 nfet_03v3 ad=2.08p pd=8.52u as=2.08p ps=8.52u w=8u l=0.28u
X284 VDD.t429 a_21324_6400.t169 E_SENSE.t31 VDD.t428 pfet_03v3 ad=2.08p pd=8.52u as=2.08p ps=8.52u w=8u l=0.28u
X285 a_17292_41600.t22 a_14540_41600.t34 VDD.t191 VDD.t190 pfet_03v3 ad=2.08p pd=8.52u as=2.08p ps=8.52u w=8u l=0.28u
X286 VDD.t341 a_17292_6400.t71 a_21324_6400.t24 VDD.t340 pfet_03v3 ad=2.08p pd=8.52u as=2.08p ps=8.52u w=8u l=0.28u
X287 VSS.t249 a_21324_41600.t65 O_SENSE.t74 VSS.t248 nfet_03v3 ad=2.08p pd=8.52u as=2.08p ps=8.52u w=8u l=0.28u
X288 VSS.t49 a_4812_41600.t15 O_CAPTURE_CLK.t1 VSS.t48 nfet_03v3 ad=2.08p pd=8.52u as=3.52p ps=16.88u w=8u l=0.28u
X289 VSS.t585 a_2700_6400.t11 E_CAPTURE_CLKB.t15 VSS.t584 nfet_03v3 ad=2.08p pd=8.52u as=2.08p ps=8.52u w=8u l=0.28u
X290 VSS.t297 a_21324_41600.t87 O_SENSE.t81 VSS.t296 nfet_03v3 ad=2.08p pd=8.52u as=2.08p ps=8.52u w=8u l=0.28u
X291 a_21324_41600.t51 a_17292_41600.t82 VDD.t491 VDD.t490 pfet_03v3 ad=2.08p pd=8.52u as=2.08p ps=8.52u w=8u l=0.28u
X292 E_SENSE.t92 a_21324_6400.t96 VSS.t449 VSS.t448 nfet_03v3 ad=2.08p pd=8.52u as=2.08p ps=8.52u w=8u l=0.28u
X293 VSS.t169 a_4812_6400.t11 E_CAPTURE_CLK.t8 VSS.t168 nfet_03v3 ad=2.08p pd=8.52u as=2.08p ps=8.52u w=8u l=0.28u
X294 VSS.t107 a_14540_41600.t17 a_17292_41600.t11 VSS.t106 nfet_03v3 ad=2.08p pd=8.52u as=2.08p ps=8.52u w=8u l=0.28u
X295 O_SENSE.t63 a_21324_41600.t74 VSS.t147 VSS.t146 nfet_03v3 ad=2.08p pd=8.52u as=2.08p ps=8.52u w=8u l=0.28u
X296 VDD.t63 a_21324_41600.t149 O_SENSE.t18 VDD.t62 pfet_03v3 ad=2.08p pd=8.52u as=2.08p ps=8.52u w=8u l=0.28u
X297 VSS.t557 a_17292_6400.t61 a_21324_6400.t57 VSS.t556 nfet_03v3 ad=2.08p pd=8.52u as=2.08p ps=8.52u w=8u l=0.28u
X298 VSS.t333 CLKP_HB.t7 a_2700_6400.t0 VSS.t332 nfet_03v3 ad=2.08p pd=8.52u as=3.52p ps=16.88u w=8u l=0.28u
X299 E_SENSE.t90 a_21324_6400.t94 VSS.t445 VSS.t444 nfet_03v3 ad=2.08p pd=8.52u as=2.08p ps=8.52u w=8u l=0.28u
X300 a_17292_6400.t10 a_14540_6400.t40 VDD.t153 VDD.t152 pfet_03v3 ad=2.08p pd=8.52u as=2.08p ps=8.52u w=8u l=0.28u
X301 E_CAPTURE_CLK.t6 a_4812_6400.t20 VDD.t123 VDD.t122 pfet_03v3 ad=2.08p pd=8.52u as=2.08p ps=8.52u w=8u l=0.28u
X302 VSS.t315 a_17292_41600.t49 a_21324_41600.t45 VSS.t314 nfet_03v3 ad=2.08p pd=8.52u as=2.08p ps=8.52u w=8u l=0.28u
X303 VDD.t513 a_21324_41600.t171 O_SENSE.t108 VDD.t512 pfet_03v3 ad=2.08p pd=8.52u as=2.08p ps=8.52u w=8u l=0.28u
X304 VDD.t441 a_21324_6400.t139 E_SENSE.t37 VDD.t440 pfet_03v3 ad=2.08p pd=8.52u as=2.08p ps=8.52u w=8u l=0.28u
X305 VDD.t219 CLKN_HB.t15 a_2700_41600.t4 VDD.t218 pfet_03v3 ad=2.08p pd=8.52u as=3.52p ps=16.88u w=8u l=0.28u
X306 VSS.t363 a_17292_6400.t59 a_21324_6400.t30 VSS.t362 nfet_03v3 ad=2.08p pd=8.52u as=2.08p ps=8.52u w=8u l=0.28u
X307 a_21324_6400.t33 a_17292_6400.t94 VDD.t361 VDD.t360 pfet_03v3 ad=2.08p pd=8.52u as=2.08p ps=8.52u w=8u l=0.28u
X308 a_17292_41600.t14 a_14540_41600.t26 VSS.t113 VSS.t112 nfet_03v3 ad=2.08p pd=8.52u as=2.08p ps=8.52u w=8u l=0.28u
X309 O_SENSE.t103 a_21324_41600.t158 VDD.t503 VDD.t502 pfet_03v3 ad=2.08p pd=8.52u as=2.08p ps=8.52u w=8u l=0.28u
X310 VDD.t105 a_17292_41600.t79 a_21324_41600.t20 VDD.t104 pfet_03v3 ad=2.08p pd=8.52u as=2.08p ps=8.52u w=8u l=0.28u
X311 E_SENSE.t122 a_21324_6400.t66 VSS.t509 VSS.t508 nfet_03v3 ad=2.08p pd=8.52u as=2.08p ps=8.52u w=8u l=0.28u
X312 E_CAPTURE_CLKB.t12 a_2700_6400.t12 VSS.t323 VSS.t322 nfet_03v3 ad=2.08p pd=8.52u as=2.08p ps=8.52u w=8u l=0.28u
X313 a_2700_41600.t1 CLKN_HB.t6 VSS.t269 VSS.t268 nfet_03v3 ad=2.08p pd=8.52u as=2.08p ps=8.52u w=8u l=0.28u
X314 VSS.t525 a_21324_41600.t71 O_SENSE.t112 VSS.t524 nfet_03v3 ad=2.08p pd=8.52u as=2.08p ps=8.52u w=8u l=0.28u
X315 VDD.t213 CLKN_HB.t11 a_6924_41600.t4 VDD.t212 pfet_03v3 ad=2.08p pd=8.52u as=3.52p ps=16.88u w=8u l=0.28u
X316 VSS.t439 a_21324_6400.t97 E_SENSE.t87 VSS.t438 nfet_03v3 ad=2.08p pd=8.52u as=2.08p ps=8.52u w=8u l=0.28u
X317 a_17292_6400.t30 a_14540_6400.t32 VDD.t589 VDD.t588 pfet_03v3 ad=3.52p pd=16.88u as=2.08p ps=8.52u w=8u l=0.28u
X318 E_SENSE.t120 a_21324_6400.t64 VSS.t505 VSS.t504 nfet_03v3 ad=3.52p pd=16.88u as=2.08p ps=8.52u w=8u l=0.28u
X319 VDD.t179 a_2700_6400.t21 E_CAPTURE_CLKB.t7 VDD.t178 pfet_03v3 ad=2.08p pd=8.52u as=2.08p ps=8.52u w=8u l=0.28u
X320 VSS.t41 a_21324_41600.t93 O_SENSE.t14 VSS.t40 nfet_03v3 ad=2.08p pd=8.52u as=2.08p ps=8.52u w=8u l=0.28u
X321 VSS.t447 a_21324_6400.t95 E_SENSE.t91 VSS.t446 nfet_03v3 ad=2.08p pd=8.52u as=2.08p ps=8.52u w=8u l=0.28u
X322 E_SENSE.t0 a_21324_6400.t162 VDD.t299 VDD.t298 pfet_03v3 ad=2.08p pd=8.52u as=2.08p ps=8.52u w=8u l=0.28u
X323 a_21324_6400.t62 a_17292_6400.t64 VDD.t559 VDD.t558 pfet_03v3 ad=3.52p pd=16.88u as=2.08p ps=8.52u w=8u l=0.28u
X324 VDD.t151 a_17292_41600.t65 a_21324_41600.t30 VDD.t150 pfet_03v3 ad=2.08p pd=8.52u as=2.08p ps=8.52u w=8u l=0.28u
X325 VSS.t351 a_14540_41600.t23 a_17292_41600.t29 VSS.t350 nfet_03v3 ad=2.08p pd=8.52u as=2.08p ps=8.52u w=8u l=0.28u
X326 VDD.t399 a_21324_41600.t155 O_SENSE.t96 VDD.t398 pfet_03v3 ad=2.08p pd=8.52u as=2.08p ps=8.52u w=8u l=0.28u
X327 VDD.t357 a_17292_6400.t95 a_21324_6400.t31 VDD.t356 pfet_03v3 ad=2.08p pd=8.52u as=3.52p ps=16.88u w=8u l=0.28u
X328 VDD.t585 a_2700_41600.t23 O_CAPTURE_CLKB.t15 VDD.t584 pfet_03v3 ad=2.08p pd=8.52u as=3.52p ps=16.88u w=8u l=0.28u
X329 VSS.t135 a_21324_41600.t127 O_SENSE.t56 VSS.t134 nfet_03v3 ad=2.08p pd=8.52u as=3.52p ps=16.88u w=8u l=0.28u
X330 VSS.t101 a_17292_41600.t55 a_21324_41600.t26 VSS.t100 nfet_03v3 ad=2.08p pd=8.52u as=2.08p ps=8.52u w=8u l=0.28u
X331 VDD.t45 a_14540_41600.t37 a_17292_41600.t3 VDD.t44 pfet_03v3 ad=2.08p pd=8.52u as=2.08p ps=8.52u w=8u l=0.28u
X332 VDD.t567 a_21324_41600.t177 O_SENSE.t124 VDD.t566 pfet_03v3 ad=2.08p pd=8.52u as=2.08p ps=8.52u w=8u l=0.28u
X333 VSS.t499 a_21324_6400.t67 E_SENSE.t117 VSS.t498 nfet_03v3 ad=2.08p pd=8.52u as=2.08p ps=8.52u w=8u l=0.28u
X334 O_SENSE.t67 a_21324_41600.t90 VSS.t181 VSS.t180 nfet_03v3 ad=2.08p pd=8.52u as=2.08p ps=8.52u w=8u l=0.28u
X335 VDD.t563 a_21324_41600.t189 O_SENSE.t122 VDD.t562 pfet_03v3 ad=2.08p pd=8.52u as=2.08p ps=8.52u w=8u l=0.28u
X336 a_21324_6400.t0 a_17292_6400.t54 VSS.t215 VSS.t214 nfet_03v3 ad=2.08p pd=8.52u as=2.08p ps=8.52u w=8u l=0.28u
X337 a_4812_6400.t1 CLKP_H.t2 VSS.t275 VSS.t274 nfet_03v3 ad=2.08p pd=8.52u as=2.08p ps=8.52u w=8u l=0.28u
X338 E_SENSE.t59 a_21324_6400.t132 VDD.t485 VDD.t484 pfet_03v3 ad=2.08p pd=8.52u as=2.08p ps=8.52u w=8u l=0.28u
X339 VDD.t591 a_14540_6400.t33 a_17292_6400.t31 VDD.t590 pfet_03v3 ad=2.08p pd=8.52u as=2.08p ps=8.52u w=8u l=0.28u
X340 VDD.t67 a_21324_41600.t141 O_SENSE.t20 VDD.t66 pfet_03v3 ad=2.08p pd=8.52u as=2.08p ps=8.52u w=8u l=0.28u
X341 O_SENSE.t61 a_21324_41600.t112 VSS.t143 VSS.t142 nfet_03v3 ad=2.08p pd=8.52u as=2.08p ps=8.52u w=8u l=0.28u
X342 a_21324_6400.t5 a_17292_6400.t52 VSS.t225 VSS.t224 nfet_03v3 ad=2.08p pd=8.52u as=2.08p ps=8.52u w=8u l=0.28u
X343 VDD.t551 a_17292_6400.t87 a_21324_6400.t54 VDD.t550 pfet_03v3 ad=2.08p pd=8.52u as=2.08p ps=8.52u w=8u l=0.28u
X344 VSS.t291 a_6924_41600.t11 a_14540_41600.t13 VSS.t290 nfet_03v3 ad=2.08p pd=8.52u as=2.08p ps=8.52u w=8u l=0.28u
X345 VDD.t561 a_17292_6400.t65 a_21324_6400.t63 VDD.t560 pfet_03v3 ad=2.08p pd=8.52u as=2.08p ps=8.52u w=8u l=0.28u
X346 O_CAPTURE_CLKB.t14 a_2700_41600.t20 VDD.t549 VDD.t548 pfet_03v3 ad=2.08p pd=8.52u as=2.08p ps=8.52u w=8u l=0.28u
X347 VSS.t175 a_21324_41600.t99 O_SENSE.t64 VSS.t174 nfet_03v3 ad=2.08p pd=8.52u as=2.08p ps=8.52u w=8u l=0.28u
X348 O_SENSE.t91 a_21324_41600.t174 VDD.t389 VDD.t388 pfet_03v3 ad=2.08p pd=8.52u as=2.08p ps=8.52u w=8u l=0.28u
X349 O_SENSE.t57 a_21324_41600.t128 VDD.t169 VDD.t168 pfet_03v3 ad=3.52p pd=16.88u as=2.08p ps=8.52u w=8u l=0.28u
X350 VSS.t133 a_2700_41600.t9 O_CAPTURE_CLKB.t6 VSS.t132 nfet_03v3 ad=2.08p pd=8.52u as=2.08p ps=8.52u w=8u l=0.28u
X351 E_SENSE.t63 a_21324_6400.t124 VSS.t391 VSS.t390 nfet_03v3 ad=2.08p pd=8.52u as=2.08p ps=8.52u w=8u l=0.28u
X352 VDD.t197 a_6924_41600.t17 a_14540_41600.t9 VDD.t196 pfet_03v3 ad=2.08p pd=8.52u as=2.08p ps=8.52u w=8u l=0.28u
X353 VDD.t587 a_17292_41600.t71 a_21324_41600.t61 VDD.t586 pfet_03v3 ad=2.08p pd=8.52u as=2.08p ps=8.52u w=8u l=0.28u
X354 E_SENSE.t98 a_21324_6400.t90 VSS.t461 VSS.t460 nfet_03v3 ad=2.08p pd=8.52u as=2.08p ps=8.52u w=8u l=0.28u
X355 O_SENSE.t86 a_21324_41600.t186 VDD.t285 VDD.t284 pfet_03v3 ad=2.08p pd=8.52u as=2.08p ps=8.52u w=8u l=0.28u
X356 VSS.t191 a_4812_41600.t13 O_CAPTURE_CLK.t7 VSS.t190 nfet_03v3 ad=2.08p pd=8.52u as=2.08p ps=8.52u w=8u l=0.28u
X357 E_SENSE.t96 a_21324_6400.t88 VSS.t457 VSS.t456 nfet_03v3 ad=2.08p pd=8.52u as=2.08p ps=8.52u w=8u l=0.28u
X358 VDD.t355 a_21324_6400.t155 E_SENSE.t11 VDD.t354 pfet_03v3 ad=2.08p pd=8.52u as=2.08p ps=8.52u w=8u l=0.28u
X359 a_14540_41600.t6 a_6924_41600.t8 VSS.t187 VSS.t186 nfet_03v3 ad=3.52p pd=16.88u as=2.08p ps=8.52u w=8u l=0.28u
X360 VSS.t569 a_6924_6400.t9 a_14540_6400.t12 VSS.t568 nfet_03v3 ad=2.08p pd=8.52u as=2.08p ps=8.52u w=8u l=0.28u
X361 a_21324_41600.t63 a_17292_41600.t38 VSS.t591 VSS.t590 nfet_03v3 ad=2.08p pd=8.52u as=2.08p ps=8.52u w=8u l=0.28u
X362 O_SENSE.t77 a_21324_41600.t96 VSS.t283 VSS.t282 nfet_03v3 ad=2.08p pd=8.52u as=2.08p ps=8.52u w=8u l=0.28u
X363 VSS.t227 a_17292_6400.t53 a_21324_6400.t6 VSS.t226 nfet_03v3 ad=2.08p pd=8.52u as=2.08p ps=8.52u w=8u l=0.28u
X364 a_21324_6400.t55 a_17292_6400.t88 VDD.t553 VDD.t552 pfet_03v3 ad=2.08p pd=8.52u as=2.08p ps=8.52u w=8u l=0.28u
X365 VDD.t171 CLKN_H.t7 a_4812_41600.t4 VDD.t170 pfet_03v3 ad=2.08p pd=8.52u as=3.52p ps=16.88u w=8u l=0.28u
X366 VDD.t381 a_21324_6400.t153 E_SENSE.t15 VDD.t380 pfet_03v3 ad=2.08p pd=8.52u as=2.08p ps=8.52u w=8u l=0.28u
X367 VSS.t393 a_21324_6400.t125 E_SENSE.t64 VSS.t392 nfet_03v3 ad=2.08p pd=8.52u as=2.08p ps=8.52u w=8u l=0.28u
X368 VDD.t7 a_21324_41600.t147 O_SENSE.t0 VDD.t6 pfet_03v3 ad=2.08p pd=8.52u as=2.08p ps=8.52u w=8u l=0.28u
X369 a_21324_41600.t12 a_17292_41600.t68 VDD.t61 VDD.t60 pfet_03v3 ad=2.08p pd=8.52u as=2.08p ps=8.52u w=8u l=0.28u
X370 a_21324_41600.t2 a_17292_41600.t90 VDD.t31 VDD.t30 pfet_03v3 ad=2.08p pd=8.52u as=2.08p ps=8.52u w=8u l=0.28u
X371 E_SENSE.t40 a_21324_6400.t190 VDD.t447 VDD.t446 pfet_03v3 ad=2.08p pd=8.52u as=2.08p ps=8.52u w=8u l=0.28u
X372 VSS.t231 a_17292_6400.t47 a_21324_6400.t8 VSS.t230 nfet_03v3 ad=2.08p pd=8.52u as=2.08p ps=8.52u w=8u l=0.28u
X373 O_CAPTURE_CLK.t10 a_4812_41600.t10 VSS.t201 VSS.t200 nfet_03v3 ad=2.08p pd=8.52u as=2.08p ps=8.52u w=8u l=0.28u
X374 O_SENSE.t73 a_21324_41600.t82 VSS.t243 VSS.t242 nfet_03v3 ad=2.08p pd=8.52u as=2.08p ps=8.52u w=8u l=0.28u
X375 VDD.t87 a_17292_41600.t77 a_21324_41600.t15 VDD.t86 pfet_03v3 ad=2.08p pd=8.52u as=2.08p ps=8.52u w=8u l=0.28u
X376 VSS.t419 a_21324_6400.t111 E_SENSE.t77 VSS.t418 nfet_03v3 ad=2.08p pd=8.52u as=2.08p ps=8.52u w=8u l=0.28u
X377 E_SENSE.t6 a_21324_6400.t156 VDD.t323 VDD.t322 pfet_03v3 ad=2.08p pd=8.52u as=2.08p ps=8.52u w=8u l=0.28u
X378 VSS.t387 a_17292_6400.t45 a_21324_6400.t51 VSS.t386 nfet_03v3 ad=2.08p pd=8.52u as=2.08p ps=8.52u w=8u l=0.28u
X379 a_14540_6400.t13 a_6924_6400.t10 VSS.t571 VSS.t570 nfet_03v3 ad=2.08p pd=8.52u as=2.08p ps=8.52u w=8u l=0.28u
X380 VDD.t293 a_6924_6400.t21 a_14540_6400.t4 VDD.t292 pfet_03v3 ad=2.08p pd=8.52u as=2.08p ps=8.52u w=8u l=0.28u
X381 O_CAPTURE_CLK.t2 a_4812_41600.t16 VDD.t51 VDD.t50 pfet_03v3 ad=3.52p pd=16.88u as=2.08p ps=8.52u w=8u l=0.28u
X382 a_2700_41600.t3 CLKN_HB.t4 VSS.t263 VSS.t262 nfet_03v3 ad=3.52p pd=16.88u as=2.08p ps=8.52u w=8u l=0.28u
X383 VSS.t45 a_21324_41600.t69 O_SENSE.t16 VSS.t44 nfet_03v3 ad=2.08p pd=8.52u as=2.08p ps=8.52u w=8u l=0.28u
X384 O_SENSE.t53 a_21324_41600.t144 VDD.t163 VDD.t162 pfet_03v3 ad=2.08p pd=8.52u as=2.08p ps=8.52u w=8u l=0.28u
X385 O_SENSE.t127 a_21324_41600.t166 VDD.t573 VDD.t572 pfet_03v3 ad=2.08p pd=8.52u as=2.08p ps=8.52u w=8u l=0.28u
X386 a_14540_41600.t14 a_6924_41600.t14 VSS.t533 VSS.t532 nfet_03v3 ad=2.08p pd=8.52u as=2.08p ps=8.52u w=8u l=0.28u
X387 VDD.t37 a_6924_6400.t19 a_14540_6400.t2 VDD.t36 pfet_03v3 ad=2.08p pd=8.52u as=2.08p ps=8.52u w=8u l=0.28u
X388 a_21324_41600.t41 a_17292_41600.t44 VSS.t255 VSS.t254 nfet_03v3 ad=2.08p pd=8.52u as=2.08p ps=8.52u w=8u l=0.28u
X389 a_21324_6400.t9 a_17292_6400.t48 VSS.t233 VSS.t232 nfet_03v3 ad=2.08p pd=8.52u as=2.08p ps=8.52u w=8u l=0.28u
X390 VDD.t449 a_21324_6400.t191 E_SENSE.t41 VDD.t448 pfet_03v3 ad=2.08p pd=8.52u as=3.52p ps=16.88u w=8u l=0.28u
X391 VDD.t135 a_21324_41600.t153 O_SENSE.t36 VDD.t134 pfet_03v3 ad=2.08p pd=8.52u as=2.08p ps=8.52u w=8u l=0.28u
X392 a_17292_6400.t26 a_14540_6400.t30 VSS.t549 VSS.t548 nfet_03v3 ad=2.08p pd=8.52u as=2.08p ps=8.52u w=8u l=0.28u
X393 a_21324_41600.t36 a_17292_41600.t74 VDD.t189 VDD.t188 pfet_03v3 ad=2.08p pd=8.52u as=2.08p ps=8.52u w=8u l=0.28u
X394 VSS.t479 a_21324_6400.t81 E_SENSE.t107 VSS.t478 nfet_03v3 ad=2.08p pd=8.52u as=2.08p ps=8.52u w=8u l=0.28u
X395 E_SENSE.t22 a_21324_6400.t148 VDD.t411 VDD.t410 pfet_03v3 ad=2.08p pd=8.52u as=2.08p ps=8.52u w=8u l=0.28u
X396 E_SENSE.t72 a_21324_6400.t112 VSS.t409 VSS.t408 nfet_03v3 ad=2.08p pd=8.52u as=2.08p ps=8.52u w=8u l=0.28u
X397 a_21324_6400.t7 a_17292_6400.t46 VSS.t229 VSS.t228 nfet_03v3 ad=2.08p pd=8.52u as=2.08p ps=8.52u w=8u l=0.28u
X398 VDD.t311 a_17292_6400.t81 a_21324_6400.t13 VDD.t310 pfet_03v3 ad=2.08p pd=8.52u as=2.08p ps=8.52u w=8u l=0.28u
X399 O_SENSE.t75 a_21324_41600.t66 VSS.t251 VSS.t250 nfet_03v3 ad=2.08p pd=8.52u as=2.08p ps=8.52u w=8u l=0.28u
X400 VDD.t245 a_14540_6400.t47 a_17292_6400.t16 VDD.t244 pfet_03v3 ad=2.08p pd=8.52u as=3.52p ps=16.88u w=8u l=0.28u
X401 E_SENSE.t66 a_21324_6400.t118 VSS.t397 VSS.t396 nfet_03v3 ad=2.08p pd=8.52u as=2.08p ps=8.52u w=8u l=0.28u
X402 VDD.t461 a_21324_6400.t185 E_SENSE.t47 VDD.t460 pfet_03v3 ad=2.08p pd=8.52u as=2.08p ps=8.52u w=8u l=0.28u
X403 O_SENSE.t82 a_21324_41600.t88 VSS.t299 VSS.t298 nfet_03v3 ad=2.08p pd=8.52u as=2.08p ps=8.52u w=8u l=0.28u
X404 VDD.t469 a_21324_6400.t177 E_SENSE.t51 VDD.t468 pfet_03v3 ad=2.08p pd=8.52u as=2.08p ps=8.52u w=8u l=0.28u
X405 VSS.t21 a_17292_41600.t41 a_21324_41600.t4 VSS.t20 nfet_03v3 ad=2.08p pd=8.52u as=2.08p ps=8.52u w=8u l=0.28u
X406 a_14540_6400.t3 a_6924_6400.t20 VDD.t39 VDD.t38 pfet_03v3 ad=2.08p pd=8.52u as=2.08p ps=8.52u w=8u l=0.28u
X407 a_17292_41600.t24 a_14540_41600.t18 VSS.t341 VSS.t340 nfet_03v3 ad=2.08p pd=8.52u as=2.08p ps=8.52u w=8u l=0.28u
X408 VSS.t103 a_17292_41600.t63 a_21324_41600.t27 VSS.t102 nfet_03v3 ad=2.08p pd=8.52u as=3.52p ps=16.88u w=8u l=0.28u
X409 VDD.t377 a_21324_6400.t183 E_SENSE.t13 VDD.t376 pfet_03v3 ad=2.08p pd=8.52u as=2.08p ps=8.52u w=8u l=0.28u
X410 VDD.t187 a_14540_41600.t45 a_17292_41600.t21 VDD.t186 pfet_03v3 ad=2.08p pd=8.52u as=2.08p ps=8.52u w=8u l=0.28u
X411 O_SENSE.t19 a_21324_41600.t150 VDD.t65 VDD.t64 pfet_03v3 ad=2.08p pd=8.52u as=2.08p ps=8.52u w=8u l=0.28u
X412 E_SENSE.t82 a_21324_6400.t104 VSS.t429 VSS.t428 nfet_03v3 ad=2.08p pd=8.52u as=2.08p ps=8.52u w=8u l=0.28u
X413 O_SENSE.t109 a_21324_41600.t172 VDD.t515 VDD.t514 pfet_03v3 ad=2.08p pd=8.52u as=2.08p ps=8.52u w=8u l=0.28u
X414 E_SENSE.t102 a_21324_6400.t82 VSS.t469 VSS.t468 nfet_03v3 ad=2.08p pd=8.52u as=2.08p ps=8.52u w=8u l=0.28u
X415 VDD.t413 a_21324_6400.t149 E_SENSE.t23 VDD.t412 pfet_03v3 ad=2.08p pd=8.52u as=2.08p ps=8.52u w=8u l=0.28u
X416 a_21324_41600.t46 a_17292_41600.t50 VSS.t317 VSS.t316 nfet_03v3 ad=2.08p pd=8.52u as=2.08p ps=8.52u w=8u l=0.28u
X417 a_17292_41600.t8 a_14540_41600.t32 VDD.t131 VDD.t130 pfet_03v3 ad=3.52p pd=16.88u as=2.08p ps=8.52u w=8u l=0.28u
X418 VDD.t57 a_17292_41600.t93 a_21324_41600.t8 VDD.t56 pfet_03v3 ad=2.08p pd=8.52u as=2.08p ps=8.52u w=8u l=0.28u
X419 VSS.t129 a_21324_41600.t85 O_SENSE.t48 VSS.t128 nfet_03v3 ad=2.08p pd=8.52u as=2.08p ps=8.52u w=8u l=0.28u
X420 O_SENSE.t105 a_21324_41600.t184 VDD.t507 VDD.t506 pfet_03v3 ad=2.08p pd=8.52u as=2.08p ps=8.52u w=8u l=0.28u
X421 VDD.t409 a_21324_6400.t147 E_SENSE.t21 VDD.t408 pfet_03v3 ad=2.08p pd=8.52u as=2.08p ps=8.52u w=8u l=0.28u
X422 E_SENSE.t44 a_21324_6400.t186 VDD.t455 VDD.t454 pfet_03v3 ad=2.08p pd=8.52u as=2.08p ps=8.52u w=8u l=0.28u
X423 a_6924_6400.t7 CLKP_HB.t8 VDD.t267 VDD.t266 pfet_03v3 ad=3.52p pd=16.88u as=2.08p ps=8.52u w=8u l=0.28u
X424 VSS.t11 a_21324_41600.t107 O_SENSE.t10 VSS.t10 nfet_03v3 ad=2.08p pd=8.52u as=2.08p ps=8.52u w=8u l=0.28u
X425 VSS.t261 CLKN_HB.t7 a_2700_41600.t0 VSS.t260 nfet_03v3 ad=2.08p pd=8.52u as=3.52p ps=16.88u w=8u l=0.28u
X426 E_SENSE.t46 a_21324_6400.t184 VDD.t459 VDD.t458 pfet_03v3 ad=2.08p pd=8.52u as=2.08p ps=8.52u w=8u l=0.28u
X427 E_CAPTURE_CLKB.t4 a_2700_6400.t16 VDD.t129 VDD.t128 pfet_03v3 ad=3.52p pd=16.88u as=2.08p ps=8.52u w=8u l=0.28u
X428 VSS.t371 a_17292_6400.t41 a_21324_6400.t43 VSS.t370 nfet_03v3 ad=2.08p pd=8.52u as=2.08p ps=8.52u w=8u l=0.28u
X429 E_SENSE.t112 a_21324_6400.t74 VSS.t489 VSS.t488 nfet_03v3 ad=2.08p pd=8.52u as=2.08p ps=8.52u w=8u l=0.28u
X430 VSS.t79 a_14540_6400.t23 a_17292_6400.t4 VSS.t78 nfet_03v3 ad=2.08p pd=8.52u as=2.08p ps=8.52u w=8u l=0.28u
X431 O_SENSE.t15 a_21324_41600.t94 VSS.t43 VSS.t42 nfet_03v3 ad=2.08p pd=8.52u as=2.08p ps=8.52u w=8u l=0.28u
X432 VDD.t497 a_21324_41600.t169 O_SENSE.t100 VDD.t496 pfet_03v3 ad=2.08p pd=8.52u as=2.08p ps=8.52u w=8u l=0.28u
X433 VSS.t95 a_17292_41600.t47 a_21324_41600.t23 VSS.t94 nfet_03v3 ad=2.08p pd=8.52u as=2.08p ps=8.52u w=8u l=0.28u
X434 VDD.t175 CLKN_H.t5 a_4812_41600.t6 VDD.t174 pfet_03v3 ad=2.08p pd=8.52u as=2.08p ps=8.52u w=8u l=0.28u
X435 VSS.t431 a_21324_6400.t105 E_SENSE.t83 VSS.t430 nfet_03v3 ad=2.08p pd=8.52u as=2.08p ps=8.52u w=8u l=0.28u
X436 VSS.t367 a_17292_6400.t39 a_21324_6400.t41 VSS.t366 nfet_03v3 ad=2.08p pd=8.52u as=2.08p ps=8.52u w=8u l=0.28u
X437 a_21324_6400.t21 a_17292_6400.t74 VDD.t335 VDD.t334 pfet_03v3 ad=2.08p pd=8.52u as=2.08p ps=8.52u w=8u l=0.28u
X438 a_21324_41600.t43 a_17292_41600.t66 VDD.t239 VDD.t238 pfet_03v3 ad=2.08p pd=8.52u as=2.08p ps=8.52u w=8u l=0.28u
X439 VDD.t493 a_21324_41600.t181 O_SENSE.t98 VDD.t492 pfet_03v3 ad=2.08p pd=8.52u as=2.08p ps=8.52u w=8u l=0.28u
X440 VSS.t259 CLKN_HB.t3 a_6924_41600.t0 VSS.t258 nfet_03v3 ad=2.08p pd=8.52u as=3.52p ps=16.88u w=8u l=0.28u
X441 E_SENSE.t26 a_21324_6400.t170 VDD.t419 VDD.t418 pfet_03v3 ad=2.08p pd=8.52u as=2.08p ps=8.52u w=8u l=0.28u
X442 O_SENSE.t125 a_21324_41600.t178 VDD.t569 VDD.t568 pfet_03v3 ad=2.08p pd=8.52u as=2.08p ps=8.52u w=8u l=0.28u
X443 a_21324_6400.t19 a_17292_6400.t72 VDD.t331 VDD.t330 pfet_03v3 ad=2.08p pd=8.52u as=2.08p ps=8.52u w=8u l=0.28u
X444 VDD.t261 CLKP_HB.t9 a_6924_6400.t6 VDD.t260 pfet_03v3 ad=2.08p pd=8.52u as=2.08p ps=8.52u w=8u l=0.28u
X445 VDD.t223 CLKN_HB.t9 a_6924_41600.t6 VDD.t222 pfet_03v3 ad=2.08p pd=8.52u as=2.08p ps=8.52u w=8u l=0.28u
X446 VSS.t539 a_17292_41600.t33 a_21324_41600.t55 VSS.t538 nfet_03v3 ad=2.08p pd=8.52u as=2.08p ps=8.52u w=8u l=0.28u
X447 VSS.t87 a_21324_41600.t91 O_SENSE.t32 VSS.t86 nfet_03v3 ad=2.08p pd=8.52u as=2.08p ps=8.52u w=8u l=0.28u
X448 O_SENSE.t123 a_21324_41600.t190 VDD.t565 VDD.t564 pfet_03v3 ad=2.08p pd=8.52u as=2.08p ps=8.52u w=8u l=0.28u
X449 VSS.t73 a_2700_41600.t15 O_CAPTURE_CLKB.t4 VSS.t72 nfet_03v3 ad=2.08p pd=8.52u as=3.52p ps=16.88u w=8u l=0.28u
X450 a_17292_6400.t5 a_14540_6400.t24 VSS.t81 VSS.t80 nfet_03v3 ad=2.08p pd=8.52u as=2.08p ps=8.52u w=8u l=0.28u
X451 VDD.t249 a_4812_6400.t23 E_CAPTURE_CLK.t10 VDD.t248 pfet_03v3 ad=2.08p pd=8.52u as=3.52p ps=16.88u w=8u l=0.28u
X452 VSS.t491 a_21324_6400.t75 E_SENSE.t113 VSS.t490 nfet_03v3 ad=2.08p pd=8.52u as=2.08p ps=8.52u w=8u l=0.28u
X453 E_CAPTURE_CLK.t4 a_4812_6400.t12 VSS.t75 VSS.t74 nfet_03v3 ad=2.08p pd=8.52u as=2.08p ps=8.52u w=8u l=0.28u
X454 E_SENSE.t28 a_21324_6400.t142 VDD.t423 VDD.t422 pfet_03v3 ad=2.08p pd=8.52u as=2.08p ps=8.52u w=8u l=0.28u
X455 VSS.t125 a_21324_41600.t113 O_SENSE.t46 VSS.t124 nfet_03v3 ad=2.08p pd=8.52u as=2.08p ps=8.52u w=8u l=0.28u
X456 VSS.t347 a_14540_41600.t21 a_17292_41600.t27 VSS.t346 nfet_03v3 ad=2.08p pd=8.52u as=2.08p ps=8.52u w=8u l=0.28u
X457 a_21324_6400.t58 a_17292_6400.t62 VSS.t559 VSS.t558 nfet_03v3 ad=2.08p pd=8.52u as=2.08p ps=8.52u w=8u l=0.28u
X458 VDD.t371 a_17292_6400.t75 a_21324_6400.t38 VDD.t370 pfet_03v3 ad=2.08p pd=8.52u as=2.08p ps=8.52u w=8u l=0.28u
X459 VDD.t251 a_2700_41600.t21 O_CAPTURE_CLKB.t10 VDD.t250 pfet_03v3 ad=2.08p pd=8.52u as=2.08p ps=8.52u w=8u l=0.28u
X460 VDD.t155 a_14540_6400.t41 a_17292_6400.t11 VDD.t154 pfet_03v3 ad=2.08p pd=8.52u as=2.08p ps=8.52u w=8u l=0.28u
X461 VDD.t575 a_4812_6400.t21 E_CAPTURE_CLK.t15 VDD.t574 pfet_03v3 ad=2.08p pd=8.52u as=2.08p ps=8.52u w=8u l=0.28u
X462 VDD.t107 a_17292_41600.t85 a_21324_41600.t21 VDD.t106 pfet_03v3 ad=2.08p pd=8.52u as=2.08p ps=8.52u w=8u l=0.28u
X463 E_SENSE.t38 a_21324_6400.t140 VDD.t443 VDD.t442 pfet_03v3 ad=2.08p pd=8.52u as=2.08p ps=8.52u w=8u l=0.28u
X464 VSS.t61 a_21324_41600.t125 O_SENSE.t24 VSS.t60 nfet_03v3 ad=2.08p pd=8.52u as=2.08p ps=8.52u w=8u l=0.28u
X465 VDD.t533 a_21324_41600.t175 O_SENSE.t116 VDD.t532 pfet_03v3 ad=2.08p pd=8.52u as=2.08p ps=8.52u w=8u l=0.28u
X466 VDD.t465 a_21324_6400.t179 E_SENSE.t49 VDD.t464 pfet_03v3 ad=2.08p pd=8.52u as=2.08p ps=8.52u w=8u l=0.28u
X467 VDD.t421 a_21324_6400.t171 E_SENSE.t27 VDD.t420 pfet_03v3 ad=2.08p pd=8.52u as=2.08p ps=8.52u w=8u l=0.28u
X468 VSS.t183 a_21324_41600.t77 O_SENSE.t68 VSS.t182 nfet_03v3 ad=2.08p pd=8.52u as=2.08p ps=8.52u w=8u l=0.28u
X469 a_21324_41600.t9 a_17292_41600.t72 VDD.t59 VDD.t58 pfet_03v3 ad=2.08p pd=8.52u as=2.08p ps=8.52u w=8u l=0.28u
X470 VDD.t529 a_21324_41600.t187 O_SENSE.t114 VDD.t528 pfet_03v3 ad=2.08p pd=8.52u as=2.08p ps=8.52u w=8u l=0.28u
X471 O_CAPTURE_CLKB.t7 a_2700_41600.t12 VSS.t213 VSS.t212 nfet_03v3 ad=2.08p pd=8.52u as=2.08p ps=8.52u w=8u l=0.28u
X472 a_17292_6400.t12 a_14540_6400.t16 VSS.t149 VSS.t148 nfet_03v3 ad=3.52p pd=16.88u as=2.08p ps=8.52u w=8u l=0.28u
X473 VSS.t35 a_2700_6400.t13 E_CAPTURE_CLKB.t0 VSS.t34 nfet_03v3 ad=2.08p pd=8.52u as=2.08p ps=8.52u w=8u l=0.28u
X474 O_SENSE.t80 a_21324_41600.t64 VSS.t293 VSS.t292 nfet_03v3 ad=3.52p pd=16.88u as=2.08p ps=8.52u w=8u l=0.28u
X475 O_SENSE.t29 a_21324_41600.t110 VSS.t71 VSS.t70 nfet_03v3 ad=2.08p pd=8.52u as=2.08p ps=8.52u w=8u l=0.28u
X476 VDD.t11 a_21324_41600.t139 O_SENSE.t2 VDD.t10 pfet_03v3 ad=2.08p pd=8.52u as=2.08p ps=8.52u w=8u l=0.28u
X477 E_SENSE.t88 a_21324_6400.t98 VSS.t441 VSS.t440 nfet_03v3 ad=2.08p pd=8.52u as=2.08p ps=8.52u w=8u l=0.28u
X478 a_21324_6400.t52 a_17292_6400.t32 VSS.t517 VSS.t516 nfet_03v3 ad=3.52p pd=16.88u as=2.08p ps=8.52u w=8u l=0.28u
X479 VDD.t345 a_17292_6400.t67 a_21324_6400.t26 VDD.t344 pfet_03v3 ad=2.08p pd=8.52u as=2.08p ps=8.52u w=8u l=0.28u
X480 VSS.t189 a_6924_41600.t9 a_14540_41600.t7 VSS.t188 nfet_03v3 ad=2.08p pd=8.52u as=2.08p ps=8.52u w=8u l=0.28u
X481 VSS.t51 a_17292_41600.t39 a_21324_41600.t10 VSS.t50 nfet_03v3 ad=2.08p pd=8.52u as=2.08p ps=8.52u w=8u l=0.28u
X482 O_CAPTURE_CLKB.t9 a_2700_41600.t18 VDD.t203 VDD.t202 pfet_03v3 ad=2.08p pd=8.52u as=2.08p ps=8.52u w=8u l=0.28u
X483 E_CAPTURE_CLKB.t14 a_2700_6400.t22 VDD.t581 VDD.t580 pfet_03v3 ad=2.08p pd=8.52u as=2.08p ps=8.52u w=8u l=0.28u
X484 O_SENSE.t45 a_21324_41600.t122 VSS.t123 VSS.t122 nfet_03v3 ad=2.08p pd=8.52u as=2.08p ps=8.52u w=8u l=0.28u
X485 VSS.t567 a_17292_6400.t63 a_21324_6400.t61 VSS.t566 nfet_03v3 ad=2.08p pd=8.52u as=3.52p ps=16.88u w=8u l=0.28u
X486 VDD.t301 a_21324_6400.t163 E_SENSE.t1 VDD.t300 pfet_03v3 ad=2.08p pd=8.52u as=2.08p ps=8.52u w=8u l=0.28u
X487 VDD.t445 a_21324_6400.t141 E_SENSE.t39 VDD.t444 pfet_03v3 ad=2.08p pd=8.52u as=2.08p ps=8.52u w=8u l=0.28u
X488 E_CAPTURE_CLK.t0 a_4812_6400.t22 VDD.t1 VDD.t0 pfet_03v3 ad=2.08p pd=8.52u as=2.08p ps=8.52u w=8u l=0.28u
X489 VDD.t5 a_14540_41600.t43 a_17292_41600.t1 VDD.t4 pfet_03v3 ad=2.08p pd=8.52u as=2.08p ps=8.52u w=8u l=0.28u
X490 VDD.t281 a_17292_41600.t69 a_21324_41600.t48 VDD.t280 pfet_03v3 ad=2.08p pd=8.52u as=2.08p ps=8.52u w=8u l=0.28u
X491 VDD.t29 a_17292_41600.t91 a_21324_41600.t1 VDD.t28 pfet_03v3 ad=2.08p pd=8.52u as=2.08p ps=8.52u w=8u l=0.28u
X492 O_SENSE.t55 a_21324_41600.t136 VDD.t167 VDD.t166 pfet_03v3 ad=2.08p pd=8.52u as=2.08p ps=8.52u w=8u l=0.28u
X493 VSS.t159 CLKN_H.t3 a_4812_41600.t0 VSS.t158 nfet_03v3 ad=2.08p pd=8.52u as=3.52p ps=16.88u w=8u l=0.28u
X494 E_SENSE.t118 a_21324_6400.t68 VSS.t501 VSS.t500 nfet_03v3 ad=2.08p pd=8.52u as=2.08p ps=8.52u w=8u l=0.28u
X495 VSS.t151 a_14540_6400.t17 a_17292_6400.t13 VSS.t150 nfet_03v3 ad=2.08p pd=8.52u as=2.08p ps=8.52u w=8u l=0.28u
X496 VDD.t479 a_21324_6400.t135 E_SENSE.t56 VDD.t478 pfet_03v3 ad=2.08p pd=8.52u as=2.08p ps=8.52u w=8u l=0.28u
X497 E_CAPTURE_CLK.t3 a_4812_6400.t16 VDD.t41 VDD.t40 pfet_03v3 ad=3.52p pd=16.88u as=2.08p ps=8.52u w=8u l=0.28u
X498 VSS.t529 a_21324_41600.t83 O_SENSE.t120 VSS.t528 nfet_03v3 ad=2.08p pd=8.52u as=2.08p ps=8.52u w=8u l=0.28u
X499 a_21324_41600.t50 a_17292_41600.t36 VSS.t355 VSS.t354 nfet_03v3 ad=2.08p pd=8.52u as=2.08p ps=8.52u w=8u l=0.28u
X500 VSS.t217 a_17292_6400.t55 a_21324_6400.t1 VSS.t216 nfet_03v3 ad=2.08p pd=8.52u as=2.08p ps=8.52u w=8u l=0.28u
X501 VSS.t519 a_17292_6400.t33 a_21324_6400.t53 VSS.t518 nfet_03v3 ad=2.08p pd=8.52u as=2.08p ps=8.52u w=8u l=0.28u
X502 a_21324_6400.t27 a_17292_6400.t68 VDD.t347 VDD.t346 pfet_03v3 ad=2.08p pd=8.52u as=2.08p ps=8.52u w=8u l=0.28u
X503 VDD.t475 a_21324_6400.t133 E_SENSE.t54 VDD.t474 pfet_03v3 ad=2.08p pd=8.52u as=2.08p ps=8.52u w=8u l=0.28u
X504 a_17292_6400.t8 a_14540_6400.t34 VDD.t125 VDD.t124 pfet_03v3 ad=2.08p pd=8.52u as=2.08p ps=8.52u w=8u l=0.28u
X505 VDD.t117 a_2700_6400.t23 E_CAPTURE_CLKB.t3 VDD.t116 pfet_03v3 ad=2.08p pd=8.52u as=3.52p ps=16.88u w=8u l=0.28u
X506 a_21324_41600.t25 a_17292_41600.t58 VSS.t99 VSS.t98 nfet_03v3 ad=2.08p pd=8.52u as=2.08p ps=8.52u w=8u l=0.28u
X507 a_17292_41600.t6 a_14540_41600.t40 VDD.t93 VDD.t92 pfet_03v3 ad=2.08p pd=8.52u as=2.08p ps=8.52u w=8u l=0.28u
X508 VDD.t139 a_21324_41600.t145 O_SENSE.t38 VDD.t138 pfet_03v3 ad=2.08p pd=8.52u as=2.08p ps=8.52u w=8u l=0.28u
X509 E_SENSE.t126 a_21324_6400.t164 VDD.t541 VDD.t540 pfet_03v3 ad=2.08p pd=8.52u as=2.08p ps=8.52u w=8u l=0.28u
X510 a_21324_6400.t25 a_17292_6400.t66 VDD.t343 VDD.t342 pfet_03v3 ad=2.08p pd=8.52u as=2.08p ps=8.52u w=8u l=0.28u
X511 VSS.t55 a_17292_41600.t45 a_21324_41600.t13 VSS.t54 nfet_03v3 ad=2.08p pd=8.52u as=2.08p ps=8.52u w=8u l=0.28u
X512 a_21324_41600.t19 a_17292_41600.t88 VDD.t103 VDD.t102 pfet_03v3 ad=2.08p pd=8.52u as=2.08p ps=8.52u w=8u l=0.28u
X513 O_CAPTURE_CLK.t15 a_4812_41600.t8 VSS.t537 VSS.t536 nfet_03v3 ad=3.52p pd=16.88u as=2.08p ps=8.52u w=8u l=0.28u
X514 O_SENSE.t79 a_21324_41600.t80 VSS.t287 VSS.t286 nfet_03v3 ad=2.08p pd=8.52u as=2.08p ps=8.52u w=8u l=0.28u
X515 VSS.t451 a_21324_6400.t91 E_SENSE.t93 VSS.t450 nfet_03v3 ad=2.08p pd=8.52u as=2.08p ps=8.52u w=8u l=0.28u
X516 E_SENSE.t32 a_21324_6400.t136 VDD.t431 VDD.t430 pfet_03v3 ad=2.08p pd=8.52u as=2.08p ps=8.52u w=8u l=0.28u
X517 VDD.t23 a_4812_6400.t17 E_CAPTURE_CLK.t2 VDD.t22 pfet_03v3 ad=2.08p pd=8.52u as=2.08p ps=8.52u w=8u l=0.28u
X518 O_SENSE.t31 a_21324_41600.t102 VSS.t85 VSS.t84 nfet_03v3 ad=2.08p pd=8.52u as=2.08p ps=8.52u w=8u l=0.28u
X519 a_21324_6400.t2 a_17292_6400.t56 VSS.t219 VSS.t218 nfet_03v3 ad=2.08p pd=8.52u as=2.08p ps=8.52u w=8u l=0.28u
X520 O_SENSE.t21 a_21324_41600.t142 VDD.t69 VDD.t68 pfet_03v3 ad=2.08p pd=8.52u as=2.08p ps=8.52u w=8u l=0.28u
X521 VSS.t459 a_21324_6400.t89 E_SENSE.t97 VSS.t458 nfet_03v3 ad=2.08p pd=8.52u as=2.08p ps=8.52u w=8u l=0.28u
X522 VDD.t127 a_14540_6400.t35 a_17292_6400.t9 VDD.t126 pfet_03v3 ad=2.08p pd=8.52u as=2.08p ps=8.52u w=8u l=0.28u
X523 E_SENSE.t55 a_21324_6400.t134 VDD.t477 VDD.t476 pfet_03v3 ad=2.08p pd=8.52u as=2.08p ps=8.52u w=8u l=0.28u
X524 a_14540_41600.t2 a_6924_41600.t20 VDD.t47 VDD.t46 pfet_03v3 ad=2.08p pd=8.52u as=2.08p ps=8.52u w=8u l=0.28u
X525 VSS.t179 a_21324_41600.t89 O_SENSE.t66 VSS.t178 nfet_03v3 ad=2.08p pd=8.52u as=2.08p ps=8.52u w=8u l=0.28u
X526 a_21324_41600.t5 a_17292_41600.t42 VSS.t23 VSS.t22 nfet_03v3 ad=2.08p pd=8.52u as=2.08p ps=8.52u w=8u l=0.28u
X527 O_SENSE.t119 a_21324_41600.t164 VDD.t539 VDD.t538 pfet_03v3 ad=2.08p pd=8.52u as=2.08p ps=8.52u w=8u l=0.28u
X528 VDD.t555 a_17292_6400.t89 a_21324_6400.t59 VDD.t554 pfet_03v3 ad=2.08p pd=8.52u as=2.08p ps=8.52u w=8u l=0.28u
X529 E_SENSE.t65 a_21324_6400.t126 VSS.t395 VSS.t394 nfet_03v3 ad=2.08p pd=8.52u as=2.08p ps=8.52u w=8u l=0.28u
X530 a_17292_41600.t30 a_14540_41600.t46 VDD.t277 VDD.t276 pfet_03v3 ad=2.08p pd=8.52u as=2.08p ps=8.52u w=8u l=0.28u
X531 E_CAPTURE_CLKB.t8 a_2700_6400.t18 VDD.t207 VDD.t206 pfet_03v3 ad=2.08p pd=8.52u as=2.08p ps=8.52u w=8u l=0.28u
X532 a_21324_41600.t16 a_17292_41600.t94 VDD.t89 VDD.t88 pfet_03v3 ad=2.08p pd=8.52u as=2.08p ps=8.52u w=8u l=0.28u
X533 E_SENSE.t94 a_21324_6400.t92 VSS.t453 VSS.t452 nfet_03v3 ad=2.08p pd=8.52u as=2.08p ps=8.52u w=8u l=0.28u
X534 O_CAPTURE_CLK.t12 a_4812_41600.t22 VDD.t235 VDD.t234 pfet_03v3 ad=2.08p pd=8.52u as=2.08p ps=8.52u w=8u l=0.28u
X535 VSS.t561 a_6924_6400.t13 a_14540_6400.t9 VSS.t560 nfet_03v3 ad=2.08p pd=8.52u as=2.08p ps=8.52u w=8u l=0.28u
X536 VSS.t173 a_14540_41600.t29 a_17292_41600.t17 VSS.t172 nfet_03v3 ad=2.08p pd=8.52u as=2.08p ps=8.52u w=8u l=0.28u
X537 a_2700_6400.t5 CLKP_HB.t14 VDD.t265 VDD.t264 pfet_03v3 ad=2.08p pd=8.52u as=2.08p ps=8.52u w=8u l=0.28u
X538 O_SENSE.t49 a_21324_41600.t86 VSS.t131 VSS.t130 nfet_03v3 ad=2.08p pd=8.52u as=2.08p ps=8.52u w=8u l=0.28u
X539 VDD.t391 a_21324_41600.t161 O_SENSE.t92 VDD.t390 pfet_03v3 ad=2.08p pd=8.52u as=2.08p ps=8.52u w=8u l=0.28u
X540 VDD.t325 a_21324_6400.t157 E_SENSE.t7 VDD.t324 pfet_03v3 ad=2.08p pd=8.52u as=2.08p ps=8.52u w=8u l=0.28u
X541 VSS.t573 a_6924_6400.t11 a_14540_6400.t14 VSS.t572 nfet_03v3 ad=2.08p pd=8.52u as=2.08p ps=8.52u w=8u l=0.28u
X542 a_14540_6400.t5 a_6924_6400.t22 VDD.t295 VDD.t294 pfet_03v3 ad=2.08p pd=8.52u as=2.08p ps=8.52u w=8u l=0.28u
X543 VSS.t211 a_17292_41600.t61 a_21324_41600.t37 VSS.t210 nfet_03v3 ad=2.08p pd=8.52u as=2.08p ps=8.52u w=8u l=0.28u
X544 a_2700_6400.t7 CLKP_HB.t12 VDD.t269 VDD.t268 pfet_03v3 ad=3.52p pd=16.88u as=2.08p ps=8.52u w=8u l=0.28u
X545 O_SENSE.t11 a_21324_41600.t108 VSS.t13 VSS.t12 nfet_03v3 ad=2.08p pd=8.52u as=2.08p ps=8.52u w=8u l=0.28u
X546 a_17292_41600.t10 a_14540_41600.t16 VSS.t105 VSS.t104 nfet_03v3 ad=3.52p pd=16.88u as=2.08p ps=8.52u w=8u l=0.28u
X547 a_21324_6400.t60 a_17292_6400.t90 VDD.t557 VDD.t556 pfet_03v3 ad=2.08p pd=8.52u as=2.08p ps=8.52u w=8u l=0.28u
X548 O_SENSE.t1 a_21324_41600.t148 VDD.t9 VDD.t8 pfet_03v3 ad=2.08p pd=8.52u as=2.08p ps=8.52u w=8u l=0.28u
X549 VSS.t389 a_21324_6400.t127 E_SENSE.t60 VSS.t388 nfet_03v3 ad=2.08p pd=8.52u as=3.52p ps=16.88u w=8u l=0.28u
X550 E_SENSE.t104 a_21324_6400.t84 VSS.t473 VSS.t472 nfet_03v3 ad=2.08p pd=8.52u as=2.08p ps=8.52u w=8u l=0.28u
X551 O_SENSE.t59 a_21324_41600.t120 VSS.t139 VSS.t138 nfet_03v3 ad=2.08p pd=8.52u as=2.08p ps=8.52u w=8u l=0.28u
X552 a_4812_41600.t5 CLKN_H.t6 VDD.t173 VDD.t172 pfet_03v3 ad=2.08p pd=8.52u as=2.08p ps=8.52u w=8u l=0.28u
X553 O_SENSE.t101 a_21324_41600.t170 VDD.t499 VDD.t498 pfet_03v3 ad=2.08p pd=8.52u as=2.08p ps=8.52u w=8u l=0.28u
X554 VDD.t489 a_21324_6400.t129 E_SENSE.t62 VDD.t488 pfet_03v3 ad=2.08p pd=8.52u as=2.08p ps=8.52u w=8u l=0.28u
X555 VDD.t97 a_4812_41600.t19 O_CAPTURE_CLK.t5 VDD.t96 pfet_03v3 ad=2.08p pd=8.52u as=2.08p ps=8.52u w=8u l=0.28u
X556 VSS.t235 a_17292_6400.t49 a_21324_6400.t10 VSS.t234 nfet_03v3 ad=2.08p pd=8.52u as=2.08p ps=8.52u w=8u l=0.28u
X557 VSS.t587 a_14540_6400.t31 a_17292_6400.t29 VSS.t586 nfet_03v3 ad=2.08p pd=8.52u as=3.52p ps=16.88u w=8u l=0.28u
X558 a_4812_6400.t7 CLKP_H.t4 VDD.t231 VDD.t230 pfet_03v3 ad=3.52p pd=16.88u as=2.08p ps=8.52u w=8u l=0.28u
X559 O_SENSE.t99 a_21324_41600.t182 VDD.t495 VDD.t494 pfet_03v3 ad=2.08p pd=8.52u as=2.08p ps=8.52u w=8u l=0.28u
X560 VSS.t511 a_21324_6400.t121 E_SENSE.t123 VSS.t510 nfet_03v3 ad=2.08p pd=8.52u as=2.08p ps=8.52u w=8u l=0.28u
X561 VSS.t411 a_21324_6400.t113 E_SENSE.t73 VSS.t410 nfet_03v3 ad=2.08p pd=8.52u as=2.08p ps=8.52u w=8u l=0.28u
X562 VSS.t163 CLKN_H.t1 a_4812_41600.t2 VSS.t162 nfet_03v3 ad=2.08p pd=8.52u as=2.08p ps=8.52u w=8u l=0.28u
X563 a_21324_6400.t14 a_17292_6400.t82 VDD.t313 VDD.t312 pfet_03v3 ad=2.08p pd=8.52u as=2.08p ps=8.52u w=8u l=0.28u
X564 VSS.t521 a_21324_41600.t105 O_SENSE.t110 VSS.t520 nfet_03v3 ad=2.08p pd=8.52u as=2.08p ps=8.52u w=8u l=0.28u
X565 VDD.t215 CLKN_HB.t13 a_2700_41600.t6 VDD.t214 pfet_03v3 ad=2.08p pd=8.52u as=2.08p ps=8.52u w=8u l=0.28u
X566 O_SENSE.t23 a_21324_41600.t134 VDD.t73 VDD.t72 pfet_03v3 ad=2.08p pd=8.52u as=2.08p ps=8.52u w=8u l=0.28u
X567 a_6924_41600.t5 CLKN_HB.t10 VDD.t211 VDD.t210 pfet_03v3 ad=2.08p pd=8.52u as=2.08p ps=8.52u w=8u l=0.28u
X568 VSS.t399 a_21324_6400.t119 E_SENSE.t67 VSS.t398 nfet_03v3 ad=2.08p pd=8.52u as=2.08p ps=8.52u w=8u l=0.28u
X569 a_14540_6400.t15 a_6924_6400.t12 VSS.t575 VSS.t574 nfet_03v3 ad=2.08p pd=8.52u as=2.08p ps=8.52u w=8u l=0.28u
X570 VDD.t517 a_6924_6400.t23 a_14540_6400.t8 VDD.t516 pfet_03v3 ad=2.08p pd=8.52u as=3.52p ps=16.88u w=8u l=0.28u
X571 VDD.t271 CLKP_HB.t13 a_2700_6400.t6 VDD.t270 pfet_03v3 ad=2.08p pd=8.52u as=2.08p ps=8.52u w=8u l=0.28u
X572 a_21324_41600.t56 a_17292_41600.t34 VSS.t541 VSS.t540 nfet_03v3 ad=2.08p pd=8.52u as=2.08p ps=8.52u w=8u l=0.28u
X573 VDD.t21 a_6924_41600.t23 a_14540_41600.t1 VDD.t20 pfet_03v3 ad=2.08p pd=8.52u as=3.52p ps=16.88u w=8u l=0.28u
X574 E_SENSE.t48 a_21324_6400.t178 VDD.t463 VDD.t462 pfet_03v3 ad=2.08p pd=8.52u as=2.08p ps=8.52u w=8u l=0.28u
X575 VSS.t65 a_21324_41600.t117 O_SENSE.t26 VSS.t64 nfet_03v3 ad=2.08p pd=8.52u as=2.08p ps=8.52u w=8u l=0.28u
X576 VDD.t395 a_21324_41600.t167 O_SENSE.t94 VDD.t394 pfet_03v3 ad=2.08p pd=8.52u as=2.08p ps=8.52u w=8u l=0.28u
X577 VSS.t463 a_21324_6400.t85 E_SENSE.t99 VSS.t462 nfet_03v3 ad=2.08p pd=8.52u as=2.08p ps=8.52u w=8u l=0.28u
X578 VDD.t225 CLKP_H.t7 a_4812_6400.t4 VDD.t224 pfet_03v3 ad=2.08p pd=8.52u as=3.52p ps=16.88u w=8u l=0.28u
X579 O_SENSE.t47 a_21324_41600.t114 VSS.t127 VSS.t126 nfet_03v3 ad=2.08p pd=8.52u as=2.08p ps=8.52u w=8u l=0.28u
X580 a_21324_41600.t44 a_17292_41600.t64 VDD.t241 VDD.t240 pfet_03v3 ad=3.52p pd=16.88u as=2.08p ps=8.52u w=8u l=0.28u
X581 VSS.t267 CLKN_HB.t1 a_6924_41600.t2 VSS.t266 nfet_03v3 ad=2.08p pd=8.52u as=2.08p ps=8.52u w=8u l=0.28u
X582 VDD.t289 a_21324_41600.t179 O_SENSE.t88 VDD.t288 pfet_03v3 ad=2.08p pd=8.52u as=2.08p ps=8.52u w=8u l=0.28u
X583 O_CAPTURE_CLKB.t11 a_2700_41600.t22 VDD.t253 VDD.t252 pfet_03v3 ad=2.08p pd=8.52u as=2.08p ps=8.52u w=8u l=0.28u
X584 VSS.t471 a_21324_6400.t83 E_SENSE.t103 VSS.t470 nfet_03v3 ad=2.08p pd=8.52u as=2.08p ps=8.52u w=8u l=0.28u
X585 E_SENSE.t18 a_21324_6400.t150 VDD.t403 VDD.t402 pfet_03v3 ad=2.08p pd=8.52u as=2.08p ps=8.52u w=8u l=0.28u
X586 E_SENSE.t124 a_21324_6400.t122 VSS.t513 VSS.t512 nfet_03v3 ad=2.08p pd=8.52u as=2.08p ps=8.52u w=8u l=0.28u
X587 VDD.t229 CLKP_H.t5 a_4812_6400.t6 VDD.t228 pfet_03v3 ad=2.08p pd=8.52u as=2.08p ps=8.52u w=8u l=0.28u
X588 O_SENSE.t25 a_21324_41600.t126 VSS.t63 VSS.t62 nfet_03v3 ad=2.08p pd=8.52u as=2.08p ps=8.52u w=8u l=0.28u
X589 VDD.t15 a_21324_41600.t131 O_SENSE.t4 VDD.t14 pfet_03v3 ad=2.08p pd=8.52u as=2.08p ps=8.52u w=8u l=0.28u
X590 a_6924_6400.t3 CLKP_HB.t0 VSS.t339 VSS.t338 nfet_03v3 ad=3.52p pd=16.88u as=2.08p ps=8.52u w=8u l=0.28u
X591 VDD.t319 a_17292_6400.t83 a_21324_6400.t15 VDD.t318 pfet_03v3 ad=2.08p pd=8.52u as=2.08p ps=8.52u w=8u l=0.28u
R0 E_SENSE E_SENSE.n126 16.4093
R1 E_SENSE.n126 E_SENSE.n62 6.5392
R2 E_SENSE.n64 E_SENSE.t120 5.7796
R3 E_SENSE.n1 E_SENSE.t61 5.73764
R4 E_SENSE.n125 E_SENSE.t60 5.59012
R5 E_SENSE.n62 E_SENSE.t41 5.54817
R6 E_SENSE.n64 E_SENSE.n63 5.38537
R7 E_SENSE.n66 E_SENSE.n65 5.38537
R8 E_SENSE.n68 E_SENSE.n67 5.38537
R9 E_SENSE.n70 E_SENSE.n69 5.38537
R10 E_SENSE.n72 E_SENSE.n71 5.38537
R11 E_SENSE.n74 E_SENSE.n73 5.38537
R12 E_SENSE.n76 E_SENSE.n75 5.38537
R13 E_SENSE.n78 E_SENSE.n77 5.38537
R14 E_SENSE.n80 E_SENSE.n79 5.38537
R15 E_SENSE.n82 E_SENSE.n81 5.38537
R16 E_SENSE.n84 E_SENSE.n83 5.38537
R17 E_SENSE.n86 E_SENSE.n85 5.38537
R18 E_SENSE.n88 E_SENSE.n87 5.38537
R19 E_SENSE.n90 E_SENSE.n89 5.38537
R20 E_SENSE.n92 E_SENSE.n91 5.38537
R21 E_SENSE.n94 E_SENSE.n93 5.38537
R22 E_SENSE.n96 E_SENSE.n95 5.38537
R23 E_SENSE.n98 E_SENSE.n97 5.38537
R24 E_SENSE.n100 E_SENSE.n99 5.38537
R25 E_SENSE.n102 E_SENSE.n101 5.38537
R26 E_SENSE.n104 E_SENSE.n103 5.38537
R27 E_SENSE.n106 E_SENSE.n105 5.38537
R28 E_SENSE.n108 E_SENSE.n107 5.38537
R29 E_SENSE.n110 E_SENSE.n109 5.38537
R30 E_SENSE.n112 E_SENSE.n111 5.38537
R31 E_SENSE.n114 E_SENSE.n113 5.38537
R32 E_SENSE.n116 E_SENSE.n115 5.38537
R33 E_SENSE.n118 E_SENSE.n117 5.38537
R34 E_SENSE.n120 E_SENSE.n119 5.38537
R35 E_SENSE.n122 E_SENSE.n121 5.38537
R36 E_SENSE.n124 E_SENSE.n123 5.38537
R37 E_SENSE.n1 E_SENSE.n0 5.32067
R38 E_SENSE.n3 E_SENSE.n2 5.32067
R39 E_SENSE.n5 E_SENSE.n4 5.32067
R40 E_SENSE.n7 E_SENSE.n6 5.32067
R41 E_SENSE.n9 E_SENSE.n8 5.32067
R42 E_SENSE.n11 E_SENSE.n10 5.32067
R43 E_SENSE.n13 E_SENSE.n12 5.32067
R44 E_SENSE.n15 E_SENSE.n14 5.32067
R45 E_SENSE.n17 E_SENSE.n16 5.32067
R46 E_SENSE.n19 E_SENSE.n18 5.32067
R47 E_SENSE.n21 E_SENSE.n20 5.32067
R48 E_SENSE.n23 E_SENSE.n22 5.32067
R49 E_SENSE.n25 E_SENSE.n24 5.32067
R50 E_SENSE.n27 E_SENSE.n26 5.32067
R51 E_SENSE.n29 E_SENSE.n28 5.32067
R52 E_SENSE.n31 E_SENSE.n30 5.32067
R53 E_SENSE.n33 E_SENSE.n32 5.32067
R54 E_SENSE.n35 E_SENSE.n34 5.32067
R55 E_SENSE.n37 E_SENSE.n36 5.32067
R56 E_SENSE.n39 E_SENSE.n38 5.32067
R57 E_SENSE.n41 E_SENSE.n40 5.32067
R58 E_SENSE.n43 E_SENSE.n42 5.32067
R59 E_SENSE.n45 E_SENSE.n44 5.32067
R60 E_SENSE.n47 E_SENSE.n46 5.32067
R61 E_SENSE.n49 E_SENSE.n48 5.32067
R62 E_SENSE.n51 E_SENSE.n50 5.32067
R63 E_SENSE.n53 E_SENSE.n52 5.32067
R64 E_SENSE.n55 E_SENSE.n54 5.32067
R65 E_SENSE.n57 E_SENSE.n56 5.32067
R66 E_SENSE.n59 E_SENSE.n58 5.32067
R67 E_SENSE.n61 E_SENSE.n60 5.32067
R68 E_SENSE.n126 E_SENSE.n125 4.61063
R69 E_SENSE.n0 E_SENSE.t57 0.228
R70 E_SENSE.n0 E_SENSE.t62 0.228
R71 E_SENSE.n2 E_SENSE.t59 0.228
R72 E_SENSE.n2 E_SENSE.t58 0.228
R73 E_SENSE.n4 E_SENSE.t55 0.228
R74 E_SENSE.n4 E_SENSE.t54 0.228
R75 E_SENSE.n6 E_SENSE.t32 0.228
R76 E_SENSE.n6 E_SENSE.t56 0.228
R77 E_SENSE.n8 E_SENSE.t34 0.228
R78 E_SENSE.n8 E_SENSE.t33 0.228
R79 E_SENSE.n10 E_SENSE.t38 0.228
R80 E_SENSE.n10 E_SENSE.t37 0.228
R81 E_SENSE.n12 E_SENSE.t28 0.228
R82 E_SENSE.n12 E_SENSE.t39 0.228
R83 E_SENSE.n14 E_SENSE.t24 0.228
R84 E_SENSE.n14 E_SENSE.t29 0.228
R85 E_SENSE.n16 E_SENSE.t20 0.228
R86 E_SENSE.n16 E_SENSE.t25 0.228
R87 E_SENSE.n18 E_SENSE.t22 0.228
R88 E_SENSE.n18 E_SENSE.t21 0.228
R89 E_SENSE.n20 E_SENSE.t18 0.228
R90 E_SENSE.n20 E_SENSE.t23 0.228
R91 E_SENSE.n22 E_SENSE.t14 0.228
R92 E_SENSE.n22 E_SENSE.t19 0.228
R93 E_SENSE.n24 E_SENSE.t10 0.228
R94 E_SENSE.n24 E_SENSE.t15 0.228
R95 E_SENSE.n26 E_SENSE.t6 0.228
R96 E_SENSE.n26 E_SENSE.t11 0.228
R97 E_SENSE.n28 E_SENSE.t2 0.228
R98 E_SENSE.n28 E_SENSE.t7 0.228
R99 E_SENSE.n30 E_SENSE.t4 0.228
R100 E_SENSE.n30 E_SENSE.t3 0.228
R101 E_SENSE.n32 E_SENSE.t0 0.228
R102 E_SENSE.n32 E_SENSE.t5 0.228
R103 E_SENSE.n34 E_SENSE.t126 0.228
R104 E_SENSE.n34 E_SENSE.t1 0.228
R105 E_SENSE.n36 E_SENSE.t16 0.228
R106 E_SENSE.n36 E_SENSE.t127 0.228
R107 E_SENSE.n38 E_SENSE.t30 0.228
R108 E_SENSE.n38 E_SENSE.t17 0.228
R109 E_SENSE.n40 E_SENSE.t26 0.228
R110 E_SENSE.n40 E_SENSE.t31 0.228
R111 E_SENSE.n42 E_SENSE.t35 0.228
R112 E_SENSE.n42 E_SENSE.t27 0.228
R113 E_SENSE.n44 E_SENSE.t52 0.228
R114 E_SENSE.n44 E_SENSE.t36 0.228
R115 E_SENSE.n46 E_SENSE.t50 0.228
R116 E_SENSE.n46 E_SENSE.t53 0.228
R117 E_SENSE.n48 E_SENSE.t48 0.228
R118 E_SENSE.n48 E_SENSE.t51 0.228
R119 E_SENSE.n50 E_SENSE.t8 0.228
R120 E_SENSE.n50 E_SENSE.t49 0.228
R121 E_SENSE.n52 E_SENSE.t12 0.228
R122 E_SENSE.n52 E_SENSE.t9 0.228
R123 E_SENSE.n54 E_SENSE.t46 0.228
R124 E_SENSE.n54 E_SENSE.t13 0.228
R125 E_SENSE.n56 E_SENSE.t44 0.228
R126 E_SENSE.n56 E_SENSE.t47 0.228
R127 E_SENSE.n58 E_SENSE.t42 0.228
R128 E_SENSE.n58 E_SENSE.t45 0.228
R129 E_SENSE.n60 E_SENSE.t40 0.228
R130 E_SENSE.n60 E_SENSE.t43 0.228
R131 E_SENSE.n63 E_SENSE.t122 0.20525
R132 E_SENSE.n63 E_SENSE.t121 0.20525
R133 E_SENSE.n65 E_SENSE.t118 0.20525
R134 E_SENSE.n65 E_SENSE.t117 0.20525
R135 E_SENSE.n67 E_SENSE.t114 0.20525
R136 E_SENSE.n67 E_SENSE.t119 0.20525
R137 E_SENSE.n69 E_SENSE.t116 0.20525
R138 E_SENSE.n69 E_SENSE.t115 0.20525
R139 E_SENSE.n71 E_SENSE.t112 0.20525
R140 E_SENSE.n71 E_SENSE.t111 0.20525
R141 E_SENSE.n73 E_SENSE.t108 0.20525
R142 E_SENSE.n73 E_SENSE.t113 0.20525
R143 E_SENSE.n75 E_SENSE.t110 0.20525
R144 E_SENSE.n75 E_SENSE.t109 0.20525
R145 E_SENSE.n77 E_SENSE.t106 0.20525
R146 E_SENSE.n77 E_SENSE.t105 0.20525
R147 E_SENSE.n79 E_SENSE.t102 0.20525
R148 E_SENSE.n79 E_SENSE.t107 0.20525
R149 E_SENSE.n81 E_SENSE.t104 0.20525
R150 E_SENSE.n81 E_SENSE.t103 0.20525
R151 E_SENSE.n83 E_SENSE.t100 0.20525
R152 E_SENSE.n83 E_SENSE.t99 0.20525
R153 E_SENSE.n85 E_SENSE.t96 0.20525
R154 E_SENSE.n85 E_SENSE.t101 0.20525
R155 E_SENSE.n87 E_SENSE.t98 0.20525
R156 E_SENSE.n87 E_SENSE.t97 0.20525
R157 E_SENSE.n89 E_SENSE.t94 0.20525
R158 E_SENSE.n89 E_SENSE.t93 0.20525
R159 E_SENSE.n91 E_SENSE.t90 0.20525
R160 E_SENSE.n91 E_SENSE.t95 0.20525
R161 E_SENSE.n93 E_SENSE.t92 0.20525
R162 E_SENSE.n93 E_SENSE.t91 0.20525
R163 E_SENSE.n95 E_SENSE.t88 0.20525
R164 E_SENSE.n95 E_SENSE.t87 0.20525
R165 E_SENSE.n97 E_SENSE.t84 0.20525
R166 E_SENSE.n97 E_SENSE.t89 0.20525
R167 E_SENSE.n99 E_SENSE.t86 0.20525
R168 E_SENSE.n99 E_SENSE.t85 0.20525
R169 E_SENSE.n101 E_SENSE.t82 0.20525
R170 E_SENSE.n101 E_SENSE.t81 0.20525
R171 E_SENSE.n103 E_SENSE.t78 0.20525
R172 E_SENSE.n103 E_SENSE.t83 0.20525
R173 E_SENSE.n105 E_SENSE.t80 0.20525
R174 E_SENSE.n105 E_SENSE.t79 0.20525
R175 E_SENSE.n107 E_SENSE.t76 0.20525
R176 E_SENSE.n107 E_SENSE.t75 0.20525
R177 E_SENSE.n109 E_SENSE.t72 0.20525
R178 E_SENSE.n109 E_SENSE.t77 0.20525
R179 E_SENSE.n111 E_SENSE.t74 0.20525
R180 E_SENSE.n111 E_SENSE.t73 0.20525
R181 E_SENSE.n113 E_SENSE.t70 0.20525
R182 E_SENSE.n113 E_SENSE.t69 0.20525
R183 E_SENSE.n115 E_SENSE.t66 0.20525
R184 E_SENSE.n115 E_SENSE.t71 0.20525
R185 E_SENSE.n117 E_SENSE.t68 0.20525
R186 E_SENSE.n117 E_SENSE.t67 0.20525
R187 E_SENSE.n119 E_SENSE.t124 0.20525
R188 E_SENSE.n119 E_SENSE.t123 0.20525
R189 E_SENSE.n121 E_SENSE.t63 0.20525
R190 E_SENSE.n121 E_SENSE.t125 0.20525
R191 E_SENSE.n123 E_SENSE.t65 0.20525
R192 E_SENSE.n123 E_SENSE.t64 0.20525
R193 E_SENSE.n125 E_SENSE.n124 0.189974
R194 E_SENSE.n124 E_SENSE.n122 0.189974
R195 E_SENSE.n122 E_SENSE.n120 0.189974
R196 E_SENSE.n120 E_SENSE.n118 0.189974
R197 E_SENSE.n118 E_SENSE.n116 0.189974
R198 E_SENSE.n116 E_SENSE.n114 0.189974
R199 E_SENSE.n114 E_SENSE.n112 0.189974
R200 E_SENSE.n112 E_SENSE.n110 0.189974
R201 E_SENSE.n110 E_SENSE.n108 0.189974
R202 E_SENSE.n108 E_SENSE.n106 0.189974
R203 E_SENSE.n106 E_SENSE.n104 0.189974
R204 E_SENSE.n104 E_SENSE.n102 0.189974
R205 E_SENSE.n102 E_SENSE.n100 0.189974
R206 E_SENSE.n100 E_SENSE.n98 0.189974
R207 E_SENSE.n98 E_SENSE.n96 0.189974
R208 E_SENSE.n96 E_SENSE.n94 0.189974
R209 E_SENSE.n94 E_SENSE.n92 0.189974
R210 E_SENSE.n92 E_SENSE.n90 0.189974
R211 E_SENSE.n90 E_SENSE.n88 0.189974
R212 E_SENSE.n88 E_SENSE.n86 0.189974
R213 E_SENSE.n86 E_SENSE.n84 0.189974
R214 E_SENSE.n84 E_SENSE.n82 0.189974
R215 E_SENSE.n82 E_SENSE.n80 0.189974
R216 E_SENSE.n80 E_SENSE.n78 0.189974
R217 E_SENSE.n78 E_SENSE.n76 0.189974
R218 E_SENSE.n76 E_SENSE.n74 0.189974
R219 E_SENSE.n74 E_SENSE.n72 0.189974
R220 E_SENSE.n72 E_SENSE.n70 0.189974
R221 E_SENSE.n70 E_SENSE.n68 0.189974
R222 E_SENSE.n68 E_SENSE.n66 0.189974
R223 E_SENSE.n66 E_SENSE.n64 0.189974
R224 E_SENSE.n62 E_SENSE.n61 0.189974
R225 E_SENSE.n61 E_SENSE.n59 0.189974
R226 E_SENSE.n59 E_SENSE.n57 0.189974
R227 E_SENSE.n57 E_SENSE.n55 0.189974
R228 E_SENSE.n55 E_SENSE.n53 0.189974
R229 E_SENSE.n53 E_SENSE.n51 0.189974
R230 E_SENSE.n51 E_SENSE.n49 0.189974
R231 E_SENSE.n49 E_SENSE.n47 0.189974
R232 E_SENSE.n47 E_SENSE.n45 0.189974
R233 E_SENSE.n45 E_SENSE.n43 0.189974
R234 E_SENSE.n43 E_SENSE.n41 0.189974
R235 E_SENSE.n41 E_SENSE.n39 0.189974
R236 E_SENSE.n39 E_SENSE.n37 0.189974
R237 E_SENSE.n37 E_SENSE.n35 0.189974
R238 E_SENSE.n35 E_SENSE.n33 0.189974
R239 E_SENSE.n33 E_SENSE.n31 0.189974
R240 E_SENSE.n31 E_SENSE.n29 0.189974
R241 E_SENSE.n29 E_SENSE.n27 0.189974
R242 E_SENSE.n27 E_SENSE.n25 0.189974
R243 E_SENSE.n25 E_SENSE.n23 0.189974
R244 E_SENSE.n23 E_SENSE.n21 0.189974
R245 E_SENSE.n21 E_SENSE.n19 0.189974
R246 E_SENSE.n19 E_SENSE.n17 0.189974
R247 E_SENSE.n17 E_SENSE.n15 0.189974
R248 E_SENSE.n15 E_SENSE.n13 0.189974
R249 E_SENSE.n13 E_SENSE.n11 0.189974
R250 E_SENSE.n11 E_SENSE.n9 0.189974
R251 E_SENSE.n9 E_SENSE.n7 0.189974
R252 E_SENSE.n7 E_SENSE.n5 0.189974
R253 E_SENSE.n5 E_SENSE.n3 0.189974
R254 E_SENSE.n3 E_SENSE.n1 0.189974
R255 E_CAPTURE_CLK E_CAPTURE_CLK.n14 7.98157
R256 E_CAPTURE_CLK.n14 E_CAPTURE_CLK.n6 6.5392
R257 E_CAPTURE_CLK.n8 E_CAPTURE_CLK.t13 5.7796
R258 E_CAPTURE_CLK.n1 E_CAPTURE_CLK.t3 5.73764
R259 E_CAPTURE_CLK.n13 E_CAPTURE_CLK.t12 5.59012
R260 E_CAPTURE_CLK.n6 E_CAPTURE_CLK.t10 5.54817
R261 E_CAPTURE_CLK.n8 E_CAPTURE_CLK.n7 5.38537
R262 E_CAPTURE_CLK.n10 E_CAPTURE_CLK.n9 5.38537
R263 E_CAPTURE_CLK.n12 E_CAPTURE_CLK.n11 5.38537
R264 E_CAPTURE_CLK.n1 E_CAPTURE_CLK.n0 5.32067
R265 E_CAPTURE_CLK.n3 E_CAPTURE_CLK.n2 5.32067
R266 E_CAPTURE_CLK.n5 E_CAPTURE_CLK.n4 5.32067
R267 E_CAPTURE_CLK.n14 E_CAPTURE_CLK.n13 4.61063
R268 E_CAPTURE_CLK.n0 E_CAPTURE_CLK.t11 0.228
R269 E_CAPTURE_CLK.n0 E_CAPTURE_CLK.t2 0.228
R270 E_CAPTURE_CLK.n2 E_CAPTURE_CLK.t6 0.228
R271 E_CAPTURE_CLK.n2 E_CAPTURE_CLK.t5 0.228
R272 E_CAPTURE_CLK.n4 E_CAPTURE_CLK.t0 0.228
R273 E_CAPTURE_CLK.n4 E_CAPTURE_CLK.t15 0.228
R274 E_CAPTURE_CLK.n7 E_CAPTURE_CLK.t9 0.20525
R275 E_CAPTURE_CLK.n7 E_CAPTURE_CLK.t14 0.20525
R276 E_CAPTURE_CLK.n9 E_CAPTURE_CLK.t4 0.20525
R277 E_CAPTURE_CLK.n9 E_CAPTURE_CLK.t8 0.20525
R278 E_CAPTURE_CLK.n11 E_CAPTURE_CLK.t7 0.20525
R279 E_CAPTURE_CLK.n11 E_CAPTURE_CLK.t1 0.20525
R280 E_CAPTURE_CLK.n13 E_CAPTURE_CLK.n12 0.189974
R281 E_CAPTURE_CLK.n12 E_CAPTURE_CLK.n10 0.189974
R282 E_CAPTURE_CLK.n10 E_CAPTURE_CLK.n8 0.189974
R283 E_CAPTURE_CLK.n6 E_CAPTURE_CLK.n5 0.189974
R284 E_CAPTURE_CLK.n5 E_CAPTURE_CLK.n3 0.189974
R285 E_CAPTURE_CLK.n3 E_CAPTURE_CLK.n1 0.189974
R286 E_CAPTURE_CLKB E_CAPTURE_CLKB.n14 6.63157
R287 E_CAPTURE_CLKB.n14 E_CAPTURE_CLKB.n6 6.5392
R288 E_CAPTURE_CLKB.n8 E_CAPTURE_CLKB.t6 5.7796
R289 E_CAPTURE_CLKB.n1 E_CAPTURE_CLKB.t4 5.73764
R290 E_CAPTURE_CLKB.n13 E_CAPTURE_CLKB.t1 5.59012
R291 E_CAPTURE_CLKB.n6 E_CAPTURE_CLKB.t3 5.54817
R292 E_CAPTURE_CLKB.n8 E_CAPTURE_CLKB.n7 5.38537
R293 E_CAPTURE_CLKB.n10 E_CAPTURE_CLKB.n9 5.38537
R294 E_CAPTURE_CLKB.n12 E_CAPTURE_CLKB.n11 5.38537
R295 E_CAPTURE_CLKB.n1 E_CAPTURE_CLKB.n0 5.32067
R296 E_CAPTURE_CLKB.n3 E_CAPTURE_CLKB.n2 5.32067
R297 E_CAPTURE_CLKB.n5 E_CAPTURE_CLKB.n4 5.32067
R298 E_CAPTURE_CLKB.n14 E_CAPTURE_CLKB.n13 4.61063
R299 E_CAPTURE_CLKB.n0 E_CAPTURE_CLKB.t8 0.228
R300 E_CAPTURE_CLKB.n0 E_CAPTURE_CLKB.t11 0.228
R301 E_CAPTURE_CLKB.n2 E_CAPTURE_CLKB.t9 0.228
R302 E_CAPTURE_CLKB.n2 E_CAPTURE_CLKB.t2 0.228
R303 E_CAPTURE_CLKB.n4 E_CAPTURE_CLKB.t14 0.228
R304 E_CAPTURE_CLKB.n4 E_CAPTURE_CLKB.t7 0.228
R305 E_CAPTURE_CLKB.n7 E_CAPTURE_CLKB.t13 0.20525
R306 E_CAPTURE_CLKB.n7 E_CAPTURE_CLKB.t5 0.20525
R307 E_CAPTURE_CLKB.n9 E_CAPTURE_CLKB.t12 0.20525
R308 E_CAPTURE_CLKB.n9 E_CAPTURE_CLKB.t15 0.20525
R309 E_CAPTURE_CLKB.n11 E_CAPTURE_CLKB.t10 0.20525
R310 E_CAPTURE_CLKB.n11 E_CAPTURE_CLKB.t0 0.20525
R311 E_CAPTURE_CLKB.n13 E_CAPTURE_CLKB.n12 0.189974
R312 E_CAPTURE_CLKB.n12 E_CAPTURE_CLKB.n10 0.189974
R313 E_CAPTURE_CLKB.n10 E_CAPTURE_CLKB.n8 0.189974
R314 E_CAPTURE_CLKB.n6 E_CAPTURE_CLKB.n5 0.189974
R315 E_CAPTURE_CLKB.n5 E_CAPTURE_CLKB.n3 0.189974
R316 E_CAPTURE_CLKB.n3 E_CAPTURE_CLKB.n1 0.189974
R317 CLKP_H.n8 CLKP_H.t3 113.632
R318 CLKP_H.n5 CLKP_H.t0 113.632
R319 CLKP_H.n0 CLKP_H.t4 113.632
R320 CLKP_H.n3 CLKP_H.t7 113.632
R321 CLKP_H.n6 CLKP_H.t1 109.174
R322 CLKP_H.n7 CLKP_H.t2 109.174
R323 CLKP_H.n1 CLKP_H.t5 109.174
R324 CLKP_H.n2 CLKP_H.t6 109.174
R325 CLKP_H CLKP_H.n10 15.3874
R326 CLKP_H.n7 CLKP_H.n6 11.6805
R327 CLKP_H.n2 CLKP_H.n1 11.6805
R328 CLKP_H.n10 CLKP_H.n4 10.9291
R329 CLKP_H.n10 CLKP_H.n9 9.0005
R330 CLKP_H.n9 CLKP_H.n5 7.10487
R331 CLKP_H.n9 CLKP_H.n8 7.10487
R332 CLKP_H.n4 CLKP_H.n0 7.10487
R333 CLKP_H.n4 CLKP_H.n3 7.10487
R334 CLKP_H.n6 CLKP_H.n5 4.42851
R335 CLKP_H.n8 CLKP_H.n7 4.42851
R336 CLKP_H.n1 CLKP_H.n0 4.42851
R337 CLKP_H.n3 CLKP_H.n2 4.42851
R338 CLKP_HB.n8 CLKP_HB.t3 113.632
R339 CLKP_HB.n5 CLKP_HB.t0 113.632
R340 CLKP_HB.n3 CLKP_HB.t11 113.632
R341 CLKP_HB.n0 CLKP_HB.t8 113.632
R342 CLKP_HB.n19 CLKP_HB.t7 113.632
R343 CLKP_HB.n16 CLKP_HB.t4 113.632
R344 CLKP_HB.n11 CLKP_HB.t12 113.632
R345 CLKP_HB.n14 CLKP_HB.t15 113.632
R346 CLKP_HB.n6 CLKP_HB.t1 109.174
R347 CLKP_HB.n7 CLKP_HB.t2 109.174
R348 CLKP_HB.n1 CLKP_HB.t9 109.174
R349 CLKP_HB.n2 CLKP_HB.t10 109.174
R350 CLKP_HB.n17 CLKP_HB.t5 109.174
R351 CLKP_HB.n18 CLKP_HB.t6 109.174
R352 CLKP_HB.n12 CLKP_HB.t13 109.174
R353 CLKP_HB.n13 CLKP_HB.t14 109.174
R354 CLKP_HB.n7 CLKP_HB.n6 11.6805
R355 CLKP_HB.n2 CLKP_HB.n1 11.6805
R356 CLKP_HB.n18 CLKP_HB.n17 11.6805
R357 CLKP_HB.n13 CLKP_HB.n12 11.6805
R358 CLKP_HB.n10 CLKP_HB.n4 10.9291
R359 CLKP_HB.n21 CLKP_HB.n15 10.9291
R360 CLKP_HB.n10 CLKP_HB.n9 9.0005
R361 CLKP_HB.n21 CLKP_HB.n20 9.0005
R362 CLKP_HB.n22 CLKP_HB.n10 8.70954
R363 CLKP_HB CLKP_HB.n22 8.25354
R364 CLKP_HB.n9 CLKP_HB.n5 7.10487
R365 CLKP_HB.n9 CLKP_HB.n8 7.10487
R366 CLKP_HB.n4 CLKP_HB.n0 7.10487
R367 CLKP_HB.n4 CLKP_HB.n3 7.10487
R368 CLKP_HB.n20 CLKP_HB.n16 7.10487
R369 CLKP_HB.n20 CLKP_HB.n19 7.10487
R370 CLKP_HB.n15 CLKP_HB.n11 7.10487
R371 CLKP_HB.n15 CLKP_HB.n14 7.10487
R372 CLKP_HB.n22 CLKP_HB.n21 4.59693
R373 CLKP_HB.n6 CLKP_HB.n5 4.42851
R374 CLKP_HB.n8 CLKP_HB.n7 4.42851
R375 CLKP_HB.n1 CLKP_HB.n0 4.42851
R376 CLKP_HB.n3 CLKP_HB.n2 4.42851
R377 CLKP_HB.n17 CLKP_HB.n16 4.42851
R378 CLKP_HB.n19 CLKP_HB.n18 4.42851
R379 CLKP_HB.n12 CLKP_HB.n11 4.42851
R380 CLKP_HB.n14 CLKP_HB.n13 4.42851
R381 O_SENSE O_SENSE.n126 16.4093
R382 O_SENSE.n126 O_SENSE.n62 6.5392
R383 O_SENSE.n64 O_SENSE.t80 5.7796
R384 O_SENSE.n1 O_SENSE.t57 5.73764
R385 O_SENSE.n125 O_SENSE.t56 5.59012
R386 O_SENSE.n62 O_SENSE.t87 5.54817
R387 O_SENSE.n64 O_SENSE.n63 5.38537
R388 O_SENSE.n66 O_SENSE.n65 5.38537
R389 O_SENSE.n68 O_SENSE.n67 5.38537
R390 O_SENSE.n70 O_SENSE.n69 5.38537
R391 O_SENSE.n72 O_SENSE.n71 5.38537
R392 O_SENSE.n74 O_SENSE.n73 5.38537
R393 O_SENSE.n76 O_SENSE.n75 5.38537
R394 O_SENSE.n78 O_SENSE.n77 5.38537
R395 O_SENSE.n80 O_SENSE.n79 5.38537
R396 O_SENSE.n82 O_SENSE.n81 5.38537
R397 O_SENSE.n84 O_SENSE.n83 5.38537
R398 O_SENSE.n86 O_SENSE.n85 5.38537
R399 O_SENSE.n88 O_SENSE.n87 5.38537
R400 O_SENSE.n90 O_SENSE.n89 5.38537
R401 O_SENSE.n92 O_SENSE.n91 5.38537
R402 O_SENSE.n94 O_SENSE.n93 5.38537
R403 O_SENSE.n96 O_SENSE.n95 5.38537
R404 O_SENSE.n98 O_SENSE.n97 5.38537
R405 O_SENSE.n100 O_SENSE.n99 5.38537
R406 O_SENSE.n102 O_SENSE.n101 5.38537
R407 O_SENSE.n104 O_SENSE.n103 5.38537
R408 O_SENSE.n106 O_SENSE.n105 5.38537
R409 O_SENSE.n108 O_SENSE.n107 5.38537
R410 O_SENSE.n110 O_SENSE.n109 5.38537
R411 O_SENSE.n112 O_SENSE.n111 5.38537
R412 O_SENSE.n114 O_SENSE.n113 5.38537
R413 O_SENSE.n116 O_SENSE.n115 5.38537
R414 O_SENSE.n118 O_SENSE.n117 5.38537
R415 O_SENSE.n120 O_SENSE.n119 5.38537
R416 O_SENSE.n122 O_SENSE.n121 5.38537
R417 O_SENSE.n124 O_SENSE.n123 5.38537
R418 O_SENSE.n1 O_SENSE.n0 5.32067
R419 O_SENSE.n3 O_SENSE.n2 5.32067
R420 O_SENSE.n5 O_SENSE.n4 5.32067
R421 O_SENSE.n7 O_SENSE.n6 5.32067
R422 O_SENSE.n9 O_SENSE.n8 5.32067
R423 O_SENSE.n11 O_SENSE.n10 5.32067
R424 O_SENSE.n13 O_SENSE.n12 5.32067
R425 O_SENSE.n15 O_SENSE.n14 5.32067
R426 O_SENSE.n17 O_SENSE.n16 5.32067
R427 O_SENSE.n19 O_SENSE.n18 5.32067
R428 O_SENSE.n21 O_SENSE.n20 5.32067
R429 O_SENSE.n23 O_SENSE.n22 5.32067
R430 O_SENSE.n25 O_SENSE.n24 5.32067
R431 O_SENSE.n27 O_SENSE.n26 5.32067
R432 O_SENSE.n29 O_SENSE.n28 5.32067
R433 O_SENSE.n31 O_SENSE.n30 5.32067
R434 O_SENSE.n33 O_SENSE.n32 5.32067
R435 O_SENSE.n35 O_SENSE.n34 5.32067
R436 O_SENSE.n37 O_SENSE.n36 5.32067
R437 O_SENSE.n39 O_SENSE.n38 5.32067
R438 O_SENSE.n41 O_SENSE.n40 5.32067
R439 O_SENSE.n43 O_SENSE.n42 5.32067
R440 O_SENSE.n45 O_SENSE.n44 5.32067
R441 O_SENSE.n47 O_SENSE.n46 5.32067
R442 O_SENSE.n49 O_SENSE.n48 5.32067
R443 O_SENSE.n51 O_SENSE.n50 5.32067
R444 O_SENSE.n53 O_SENSE.n52 5.32067
R445 O_SENSE.n55 O_SENSE.n54 5.32067
R446 O_SENSE.n57 O_SENSE.n56 5.32067
R447 O_SENSE.n59 O_SENSE.n58 5.32067
R448 O_SENSE.n61 O_SENSE.n60 5.32067
R449 O_SENSE.n126 O_SENSE.n125 4.61063
R450 O_SENSE.n0 O_SENSE.t43 0.228
R451 O_SENSE.n0 O_SENSE.t42 0.228
R452 O_SENSE.n2 O_SENSE.t5 0.228
R453 O_SENSE.n2 O_SENSE.t4 0.228
R454 O_SENSE.n4 O_SENSE.t23 0.228
R455 O_SENSE.n4 O_SENSE.t22 0.228
R456 O_SENSE.n6 O_SENSE.t55 0.228
R457 O_SENSE.n6 O_SENSE.t54 0.228
R458 O_SENSE.n8 O_SENSE.t41 0.228
R459 O_SENSE.n8 O_SENSE.t40 0.228
R460 O_SENSE.n10 O_SENSE.t3 0.228
R461 O_SENSE.n10 O_SENSE.t2 0.228
R462 O_SENSE.n12 O_SENSE.t21 0.228
R463 O_SENSE.n12 O_SENSE.t20 0.228
R464 O_SENSE.n14 O_SENSE.t53 0.228
R465 O_SENSE.n14 O_SENSE.t52 0.228
R466 O_SENSE.n16 O_SENSE.t39 0.228
R467 O_SENSE.n16 O_SENSE.t38 0.228
R468 O_SENSE.n18 O_SENSE.t1 0.228
R469 O_SENSE.n18 O_SENSE.t0 0.228
R470 O_SENSE.n20 O_SENSE.t19 0.228
R471 O_SENSE.n20 O_SENSE.t18 0.228
R472 O_SENSE.n22 O_SENSE.t51 0.228
R473 O_SENSE.n22 O_SENSE.t50 0.228
R474 O_SENSE.n24 O_SENSE.t37 0.228
R475 O_SENSE.n24 O_SENSE.t36 0.228
R476 O_SENSE.n26 O_SENSE.t97 0.228
R477 O_SENSE.n26 O_SENSE.t96 0.228
R478 O_SENSE.n28 O_SENSE.t103 0.228
R479 O_SENSE.n28 O_SENSE.t102 0.228
R480 O_SENSE.n30 O_SENSE.t107 0.228
R481 O_SENSE.n30 O_SENSE.t106 0.228
R482 O_SENSE.n32 O_SENSE.t93 0.228
R483 O_SENSE.n32 O_SENSE.t92 0.228
R484 O_SENSE.n34 O_SENSE.t119 0.228
R485 O_SENSE.n34 O_SENSE.t118 0.228
R486 O_SENSE.n36 O_SENSE.t127 0.228
R487 O_SENSE.n36 O_SENSE.t126 0.228
R488 O_SENSE.n38 O_SENSE.t95 0.228
R489 O_SENSE.n38 O_SENSE.t94 0.228
R490 O_SENSE.n40 O_SENSE.t101 0.228
R491 O_SENSE.n40 O_SENSE.t100 0.228
R492 O_SENSE.n42 O_SENSE.t109 0.228
R493 O_SENSE.n42 O_SENSE.t108 0.228
R494 O_SENSE.n44 O_SENSE.t91 0.228
R495 O_SENSE.n44 O_SENSE.t90 0.228
R496 O_SENSE.n46 O_SENSE.t117 0.228
R497 O_SENSE.n46 O_SENSE.t116 0.228
R498 O_SENSE.n48 O_SENSE.t125 0.228
R499 O_SENSE.n48 O_SENSE.t124 0.228
R500 O_SENSE.n50 O_SENSE.t89 0.228
R501 O_SENSE.n50 O_SENSE.t88 0.228
R502 O_SENSE.n52 O_SENSE.t99 0.228
R503 O_SENSE.n52 O_SENSE.t98 0.228
R504 O_SENSE.n54 O_SENSE.t105 0.228
R505 O_SENSE.n54 O_SENSE.t104 0.228
R506 O_SENSE.n56 O_SENSE.t86 0.228
R507 O_SENSE.n56 O_SENSE.t85 0.228
R508 O_SENSE.n58 O_SENSE.t115 0.228
R509 O_SENSE.n58 O_SENSE.t114 0.228
R510 O_SENSE.n60 O_SENSE.t123 0.228
R511 O_SENSE.n60 O_SENSE.t122 0.228
R512 O_SENSE.n63 O_SENSE.t75 0.20525
R513 O_SENSE.n63 O_SENSE.t74 0.20525
R514 O_SENSE.n65 O_SENSE.t35 0.20525
R515 O_SENSE.n65 O_SENSE.t34 0.20525
R516 O_SENSE.n67 O_SENSE.t17 0.20525
R517 O_SENSE.n67 O_SENSE.t16 0.20525
R518 O_SENSE.n69 O_SENSE.t113 0.20525
R519 O_SENSE.n69 O_SENSE.t112 0.20525
R520 O_SENSE.n71 O_SENSE.t63 0.20525
R521 O_SENSE.n71 O_SENSE.t62 0.20525
R522 O_SENSE.n73 O_SENSE.t84 0.20525
R523 O_SENSE.n73 O_SENSE.t83 0.20525
R524 O_SENSE.n75 O_SENSE.t69 0.20525
R525 O_SENSE.n75 O_SENSE.t68 0.20525
R526 O_SENSE.n77 O_SENSE.t79 0.20525
R527 O_SENSE.n77 O_SENSE.t78 0.20525
R528 O_SENSE.n79 O_SENSE.t73 0.20525
R529 O_SENSE.n79 O_SENSE.t72 0.20525
R530 O_SENSE.n81 O_SENSE.t121 0.20525
R531 O_SENSE.n81 O_SENSE.t120 0.20525
R532 O_SENSE.n83 O_SENSE.t49 0.20525
R533 O_SENSE.n83 O_SENSE.t48 0.20525
R534 O_SENSE.n85 O_SENSE.t82 0.20525
R535 O_SENSE.n85 O_SENSE.t81 0.20525
R536 O_SENSE.n87 O_SENSE.t67 0.20525
R537 O_SENSE.n87 O_SENSE.t66 0.20525
R538 O_SENSE.n89 O_SENSE.t33 0.20525
R539 O_SENSE.n89 O_SENSE.t32 0.20525
R540 O_SENSE.n91 O_SENSE.t15 0.20525
R541 O_SENSE.n91 O_SENSE.t14 0.20525
R542 O_SENSE.n93 O_SENSE.t77 0.20525
R543 O_SENSE.n93 O_SENSE.t76 0.20525
R544 O_SENSE.n95 O_SENSE.t71 0.20525
R545 O_SENSE.n95 O_SENSE.t70 0.20525
R546 O_SENSE.n97 O_SENSE.t65 0.20525
R547 O_SENSE.n97 O_SENSE.t64 0.20525
R548 O_SENSE.n99 O_SENSE.t31 0.20525
R549 O_SENSE.n99 O_SENSE.t30 0.20525
R550 O_SENSE.n101 O_SENSE.t13 0.20525
R551 O_SENSE.n101 O_SENSE.t12 0.20525
R552 O_SENSE.n103 O_SENSE.t111 0.20525
R553 O_SENSE.n103 O_SENSE.t110 0.20525
R554 O_SENSE.n105 O_SENSE.t11 0.20525
R555 O_SENSE.n105 O_SENSE.t10 0.20525
R556 O_SENSE.n107 O_SENSE.t29 0.20525
R557 O_SENSE.n107 O_SENSE.t28 0.20525
R558 O_SENSE.n109 O_SENSE.t61 0.20525
R559 O_SENSE.n109 O_SENSE.t60 0.20525
R560 O_SENSE.n111 O_SENSE.t47 0.20525
R561 O_SENSE.n111 O_SENSE.t46 0.20525
R562 O_SENSE.n113 O_SENSE.t9 0.20525
R563 O_SENSE.n113 O_SENSE.t8 0.20525
R564 O_SENSE.n115 O_SENSE.t27 0.20525
R565 O_SENSE.n115 O_SENSE.t26 0.20525
R566 O_SENSE.n117 O_SENSE.t59 0.20525
R567 O_SENSE.n117 O_SENSE.t58 0.20525
R568 O_SENSE.n119 O_SENSE.t45 0.20525
R569 O_SENSE.n119 O_SENSE.t44 0.20525
R570 O_SENSE.n121 O_SENSE.t7 0.20525
R571 O_SENSE.n121 O_SENSE.t6 0.20525
R572 O_SENSE.n123 O_SENSE.t25 0.20525
R573 O_SENSE.n123 O_SENSE.t24 0.20525
R574 O_SENSE.n125 O_SENSE.n124 0.189974
R575 O_SENSE.n124 O_SENSE.n122 0.189974
R576 O_SENSE.n122 O_SENSE.n120 0.189974
R577 O_SENSE.n120 O_SENSE.n118 0.189974
R578 O_SENSE.n118 O_SENSE.n116 0.189974
R579 O_SENSE.n116 O_SENSE.n114 0.189974
R580 O_SENSE.n114 O_SENSE.n112 0.189974
R581 O_SENSE.n112 O_SENSE.n110 0.189974
R582 O_SENSE.n110 O_SENSE.n108 0.189974
R583 O_SENSE.n108 O_SENSE.n106 0.189974
R584 O_SENSE.n106 O_SENSE.n104 0.189974
R585 O_SENSE.n104 O_SENSE.n102 0.189974
R586 O_SENSE.n102 O_SENSE.n100 0.189974
R587 O_SENSE.n100 O_SENSE.n98 0.189974
R588 O_SENSE.n98 O_SENSE.n96 0.189974
R589 O_SENSE.n96 O_SENSE.n94 0.189974
R590 O_SENSE.n94 O_SENSE.n92 0.189974
R591 O_SENSE.n92 O_SENSE.n90 0.189974
R592 O_SENSE.n90 O_SENSE.n88 0.189974
R593 O_SENSE.n88 O_SENSE.n86 0.189974
R594 O_SENSE.n86 O_SENSE.n84 0.189974
R595 O_SENSE.n84 O_SENSE.n82 0.189974
R596 O_SENSE.n82 O_SENSE.n80 0.189974
R597 O_SENSE.n80 O_SENSE.n78 0.189974
R598 O_SENSE.n78 O_SENSE.n76 0.189974
R599 O_SENSE.n76 O_SENSE.n74 0.189974
R600 O_SENSE.n74 O_SENSE.n72 0.189974
R601 O_SENSE.n72 O_SENSE.n70 0.189974
R602 O_SENSE.n70 O_SENSE.n68 0.189974
R603 O_SENSE.n68 O_SENSE.n66 0.189974
R604 O_SENSE.n66 O_SENSE.n64 0.189974
R605 O_SENSE.n62 O_SENSE.n61 0.189974
R606 O_SENSE.n61 O_SENSE.n59 0.189974
R607 O_SENSE.n59 O_SENSE.n57 0.189974
R608 O_SENSE.n57 O_SENSE.n55 0.189974
R609 O_SENSE.n55 O_SENSE.n53 0.189974
R610 O_SENSE.n53 O_SENSE.n51 0.189974
R611 O_SENSE.n51 O_SENSE.n49 0.189974
R612 O_SENSE.n49 O_SENSE.n47 0.189974
R613 O_SENSE.n47 O_SENSE.n45 0.189974
R614 O_SENSE.n45 O_SENSE.n43 0.189974
R615 O_SENSE.n43 O_SENSE.n41 0.189974
R616 O_SENSE.n41 O_SENSE.n39 0.189974
R617 O_SENSE.n39 O_SENSE.n37 0.189974
R618 O_SENSE.n37 O_SENSE.n35 0.189974
R619 O_SENSE.n35 O_SENSE.n33 0.189974
R620 O_SENSE.n33 O_SENSE.n31 0.189974
R621 O_SENSE.n31 O_SENSE.n29 0.189974
R622 O_SENSE.n29 O_SENSE.n27 0.189974
R623 O_SENSE.n27 O_SENSE.n25 0.189974
R624 O_SENSE.n25 O_SENSE.n23 0.189974
R625 O_SENSE.n23 O_SENSE.n21 0.189974
R626 O_SENSE.n21 O_SENSE.n19 0.189974
R627 O_SENSE.n19 O_SENSE.n17 0.189974
R628 O_SENSE.n17 O_SENSE.n15 0.189974
R629 O_SENSE.n15 O_SENSE.n13 0.189974
R630 O_SENSE.n13 O_SENSE.n11 0.189974
R631 O_SENSE.n11 O_SENSE.n9 0.189974
R632 O_SENSE.n9 O_SENSE.n7 0.189974
R633 O_SENSE.n7 O_SENSE.n5 0.189974
R634 O_SENSE.n5 O_SENSE.n3 0.189974
R635 O_SENSE.n3 O_SENSE.n1 0.189974
R636 O_CAPTURE_CLK O_CAPTURE_CLK.n14 7.98157
R637 O_CAPTURE_CLK.n14 O_CAPTURE_CLK.n6 6.5392
R638 O_CAPTURE_CLK.n8 O_CAPTURE_CLK.t15 5.7796
R639 O_CAPTURE_CLK.n1 O_CAPTURE_CLK.t2 5.73764
R640 O_CAPTURE_CLK.n13 O_CAPTURE_CLK.t1 5.59012
R641 O_CAPTURE_CLK.n6 O_CAPTURE_CLK.t0 5.54817
R642 O_CAPTURE_CLK.n8 O_CAPTURE_CLK.n7 5.38537
R643 O_CAPTURE_CLK.n10 O_CAPTURE_CLK.n9 5.38537
R644 O_CAPTURE_CLK.n12 O_CAPTURE_CLK.n11 5.38537
R645 O_CAPTURE_CLK.n1 O_CAPTURE_CLK.n0 5.32067
R646 O_CAPTURE_CLK.n3 O_CAPTURE_CLK.n2 5.32067
R647 O_CAPTURE_CLK.n5 O_CAPTURE_CLK.n4 5.32067
R648 O_CAPTURE_CLK.n14 O_CAPTURE_CLK.n13 4.61063
R649 O_CAPTURE_CLK.n0 O_CAPTURE_CLK.t4 0.228
R650 O_CAPTURE_CLK.n0 O_CAPTURE_CLK.t3 0.228
R651 O_CAPTURE_CLK.n2 O_CAPTURE_CLK.t6 0.228
R652 O_CAPTURE_CLK.n2 O_CAPTURE_CLK.t5 0.228
R653 O_CAPTURE_CLK.n4 O_CAPTURE_CLK.t12 0.228
R654 O_CAPTURE_CLK.n4 O_CAPTURE_CLK.t11 0.228
R655 O_CAPTURE_CLK.n7 O_CAPTURE_CLK.t10 0.20525
R656 O_CAPTURE_CLK.n7 O_CAPTURE_CLK.t9 0.20525
R657 O_CAPTURE_CLK.n9 O_CAPTURE_CLK.t14 0.20525
R658 O_CAPTURE_CLK.n9 O_CAPTURE_CLK.t13 0.20525
R659 O_CAPTURE_CLK.n11 O_CAPTURE_CLK.t8 0.20525
R660 O_CAPTURE_CLK.n11 O_CAPTURE_CLK.t7 0.20525
R661 O_CAPTURE_CLK.n13 O_CAPTURE_CLK.n12 0.189974
R662 O_CAPTURE_CLK.n12 O_CAPTURE_CLK.n10 0.189974
R663 O_CAPTURE_CLK.n10 O_CAPTURE_CLK.n8 0.189974
R664 O_CAPTURE_CLK.n6 O_CAPTURE_CLK.n5 0.189974
R665 O_CAPTURE_CLK.n5 O_CAPTURE_CLK.n3 0.189974
R666 O_CAPTURE_CLK.n3 O_CAPTURE_CLK.n1 0.189974
R667 O_CAPTURE_CLKB O_CAPTURE_CLKB.n14 6.63157
R668 O_CAPTURE_CLKB.n14 O_CAPTURE_CLKB.n6 6.5392
R669 O_CAPTURE_CLKB.n8 O_CAPTURE_CLKB.t12 5.7796
R670 O_CAPTURE_CLKB.n1 O_CAPTURE_CLKB.t5 5.73764
R671 O_CAPTURE_CLKB.n13 O_CAPTURE_CLKB.t4 5.59012
R672 O_CAPTURE_CLKB.n6 O_CAPTURE_CLKB.t15 5.54817
R673 O_CAPTURE_CLKB.n8 O_CAPTURE_CLKB.n7 5.38537
R674 O_CAPTURE_CLKB.n10 O_CAPTURE_CLKB.n9 5.38537
R675 O_CAPTURE_CLKB.n12 O_CAPTURE_CLKB.n11 5.38537
R676 O_CAPTURE_CLKB.n1 O_CAPTURE_CLKB.n0 5.32067
R677 O_CAPTURE_CLKB.n3 O_CAPTURE_CLKB.n2 5.32067
R678 O_CAPTURE_CLKB.n5 O_CAPTURE_CLKB.n4 5.32067
R679 O_CAPTURE_CLKB.n14 O_CAPTURE_CLKB.n13 4.61063
R680 O_CAPTURE_CLKB.n0 O_CAPTURE_CLKB.t9 0.228
R681 O_CAPTURE_CLKB.n0 O_CAPTURE_CLKB.t8 0.228
R682 O_CAPTURE_CLKB.n2 O_CAPTURE_CLKB.t14 0.228
R683 O_CAPTURE_CLKB.n2 O_CAPTURE_CLKB.t13 0.228
R684 O_CAPTURE_CLKB.n4 O_CAPTURE_CLKB.t11 0.228
R685 O_CAPTURE_CLKB.n4 O_CAPTURE_CLKB.t10 0.228
R686 O_CAPTURE_CLKB.n7 O_CAPTURE_CLKB.t3 0.20525
R687 O_CAPTURE_CLKB.n7 O_CAPTURE_CLKB.t6 0.20525
R688 O_CAPTURE_CLKB.n9 O_CAPTURE_CLKB.t7 0.20525
R689 O_CAPTURE_CLKB.n9 O_CAPTURE_CLKB.t2 0.20525
R690 O_CAPTURE_CLKB.n11 O_CAPTURE_CLKB.t1 0.20525
R691 O_CAPTURE_CLKB.n11 O_CAPTURE_CLKB.t0 0.20525
R692 O_CAPTURE_CLKB.n13 O_CAPTURE_CLKB.n12 0.189974
R693 O_CAPTURE_CLKB.n12 O_CAPTURE_CLKB.n10 0.189974
R694 O_CAPTURE_CLKB.n10 O_CAPTURE_CLKB.n8 0.189974
R695 O_CAPTURE_CLKB.n6 O_CAPTURE_CLKB.n5 0.189974
R696 O_CAPTURE_CLKB.n5 O_CAPTURE_CLKB.n3 0.189974
R697 O_CAPTURE_CLKB.n3 O_CAPTURE_CLKB.n1 0.189974
R698 CLKN_H.n8 CLKN_H.t3 113.632
R699 CLKN_H.n5 CLKN_H.t0 113.632
R700 CLKN_H.n0 CLKN_H.t4 113.632
R701 CLKN_H.n3 CLKN_H.t7 113.632
R702 CLKN_H.n6 CLKN_H.t1 109.174
R703 CLKN_H.n7 CLKN_H.t2 109.174
R704 CLKN_H.n1 CLKN_H.t5 109.174
R705 CLKN_H.n2 CLKN_H.t6 109.174
R706 CLKN_H CLKN_H.n10 15.3874
R707 CLKN_H.n7 CLKN_H.n6 11.6805
R708 CLKN_H.n2 CLKN_H.n1 11.6805
R709 CLKN_H.n10 CLKN_H.n4 10.9291
R710 CLKN_H.n10 CLKN_H.n9 9.0005
R711 CLKN_H.n9 CLKN_H.n5 7.10487
R712 CLKN_H.n9 CLKN_H.n8 7.10487
R713 CLKN_H.n4 CLKN_H.n0 7.10487
R714 CLKN_H.n4 CLKN_H.n3 7.10487
R715 CLKN_H.n6 CLKN_H.n5 4.42851
R716 CLKN_H.n8 CLKN_H.n7 4.42851
R717 CLKN_H.n1 CLKN_H.n0 4.42851
R718 CLKN_H.n3 CLKN_H.n2 4.42851
R719 CLKN_HB.n8 CLKN_HB.t3 113.632
R720 CLKN_HB.n5 CLKN_HB.t0 113.632
R721 CLKN_HB.n3 CLKN_HB.t11 113.632
R722 CLKN_HB.n0 CLKN_HB.t8 113.632
R723 CLKN_HB.n19 CLKN_HB.t7 113.632
R724 CLKN_HB.n16 CLKN_HB.t4 113.632
R725 CLKN_HB.n11 CLKN_HB.t12 113.632
R726 CLKN_HB.n14 CLKN_HB.t15 113.632
R727 CLKN_HB.n6 CLKN_HB.t1 109.174
R728 CLKN_HB.n7 CLKN_HB.t2 109.174
R729 CLKN_HB.n1 CLKN_HB.t9 109.174
R730 CLKN_HB.n2 CLKN_HB.t10 109.174
R731 CLKN_HB.n17 CLKN_HB.t5 109.174
R732 CLKN_HB.n18 CLKN_HB.t6 109.174
R733 CLKN_HB.n12 CLKN_HB.t13 109.174
R734 CLKN_HB.n13 CLKN_HB.t14 109.174
R735 CLKN_HB.n7 CLKN_HB.n6 11.6805
R736 CLKN_HB.n2 CLKN_HB.n1 11.6805
R737 CLKN_HB.n18 CLKN_HB.n17 11.6805
R738 CLKN_HB.n13 CLKN_HB.n12 11.6805
R739 CLKN_HB.n10 CLKN_HB.n4 10.9291
R740 CLKN_HB.n21 CLKN_HB.n15 10.9291
R741 CLKN_HB CLKN_HB.n22 9.03615
R742 CLKN_HB.n10 CLKN_HB.n9 9.0005
R743 CLKN_HB.n21 CLKN_HB.n20 9.0005
R744 CLKN_HB.n22 CLKN_HB.n10 8.70954
R745 CLKN_HB.n9 CLKN_HB.n5 7.10487
R746 CLKN_HB.n9 CLKN_HB.n8 7.10487
R747 CLKN_HB.n4 CLKN_HB.n0 7.10487
R748 CLKN_HB.n4 CLKN_HB.n3 7.10487
R749 CLKN_HB.n20 CLKN_HB.n16 7.10487
R750 CLKN_HB.n20 CLKN_HB.n19 7.10487
R751 CLKN_HB.n15 CLKN_HB.n11 7.10487
R752 CLKN_HB.n15 CLKN_HB.n14 7.10487
R753 CLKN_HB.n22 CLKN_HB.n21 4.59693
R754 CLKN_HB.n6 CLKN_HB.n5 4.42851
R755 CLKN_HB.n8 CLKN_HB.n7 4.42851
R756 CLKN_HB.n1 CLKN_HB.n0 4.42851
R757 CLKN_HB.n3 CLKN_HB.n2 4.42851
R758 CLKN_HB.n17 CLKN_HB.n16 4.42851
R759 CLKN_HB.n19 CLKN_HB.n18 4.42851
R760 CLKN_HB.n12 CLKN_HB.n11 4.42851
R761 CLKN_HB.n14 CLKN_HB.n13 4.42851
R762 VDD.t220 VDD.t170 450.829
R763 VDD.t176 VDD.t212 450.829
R764 VDD.t208 VDD.t584 450.829
R765 VDD.t74 VDD.t26 450.829
R766 VDD.t50 VDD.t20 450.829
R767 VDD.t194 VDD.t278 450.829
R768 VDD.t130 VDD.t544 450.829
R769 VDD.t240 VDD.t286 450.829
R770 VDD.t268 VDD.t224 450.829
R771 VDD.t230 VDD.t272 450.829
R772 VDD.t266 VDD.t116 450.829
R773 VDD.t128 VDD.t248 450.829
R774 VDD.t40 VDD.t516 450.829
R775 VDD.t296 VDD.t244 450.829
R776 VDD.t588 VDD.t356 450.829
R777 VDD.t558 VDD.t448 450.829
R778 VDD.n297 VDD.t218 417.582
R779 VDD.n148 VDD.t262 417.582
R780 VDD.t218 VDD.t216 44.1994
R781 VDD.t216 VDD.t214 44.1994
R782 VDD.t214 VDD.t220 44.1994
R783 VDD.t170 VDD.t172 44.1994
R784 VDD.t172 VDD.t174 44.1994
R785 VDD.t174 VDD.t176 44.1994
R786 VDD.t212 VDD.t210 44.1994
R787 VDD.t210 VDD.t222 44.1994
R788 VDD.t222 VDD.t208 44.1994
R789 VDD.t584 VDD.t252 44.1994
R790 VDD.t252 VDD.t250 44.1994
R791 VDD.t250 VDD.t548 44.1994
R792 VDD.t548 VDD.t546 44.1994
R793 VDD.t546 VDD.t202 44.1994
R794 VDD.t202 VDD.t200 44.1994
R795 VDD.t200 VDD.t74 44.1994
R796 VDD.t26 VDD.t234 44.1994
R797 VDD.t234 VDD.t232 44.1994
R798 VDD.t232 VDD.t98 44.1994
R799 VDD.t98 VDD.t96 44.1994
R800 VDD.t96 VDD.t84 44.1994
R801 VDD.t84 VDD.t82 44.1994
R802 VDD.t82 VDD.t50 44.1994
R803 VDD.t20 VDD.t18 44.1994
R804 VDD.t18 VDD.t48 44.1994
R805 VDD.t48 VDD.t46 44.1994
R806 VDD.t46 VDD.t120 44.1994
R807 VDD.t120 VDD.t118 44.1994
R808 VDD.t118 VDD.t196 44.1994
R809 VDD.t196 VDD.t194 44.1994
R810 VDD.t278 VDD.t276 44.1994
R811 VDD.t276 VDD.t186 44.1994
R812 VDD.t186 VDD.t184 44.1994
R813 VDD.t184 VDD.t4 44.1994
R814 VDD.t4 VDD.t2 44.1994
R815 VDD.t2 VDD.t94 44.1994
R816 VDD.t94 VDD.t92 44.1994
R817 VDD.t92 VDD.t80 44.1994
R818 VDD.t80 VDD.t78 44.1994
R819 VDD.t78 VDD.t44 44.1994
R820 VDD.t44 VDD.t42 44.1994
R821 VDD.t42 VDD.t192 44.1994
R822 VDD.t192 VDD.t190 44.1994
R823 VDD.t190 VDD.t132 44.1994
R824 VDD.t132 VDD.t130 44.1994
R825 VDD.t544 VDD.t88 44.1994
R826 VDD.t88 VDD.t56 44.1994
R827 VDD.t56 VDD.t52 44.1994
R828 VDD.t52 VDD.t28 44.1994
R829 VDD.t28 VDD.t30 44.1994
R830 VDD.t30 VDD.t582 44.1994
R831 VDD.t582 VDD.t102 44.1994
R832 VDD.t102 VDD.t108 44.1994
R833 VDD.t108 VDD.t54 44.1994
R834 VDD.t54 VDD.t106 44.1994
R835 VDD.t106 VDD.t520 44.1994
R836 VDD.t520 VDD.t100 44.1994
R837 VDD.t100 VDD.t490 44.1994
R838 VDD.t490 VDD.t180 44.1994
R839 VDD.t180 VDD.t182 44.1994
R840 VDD.t182 VDD.t104 44.1994
R841 VDD.t104 VDD.t198 44.1994
R842 VDD.t198 VDD.t86 44.1994
R843 VDD.t86 VDD.t24 44.1994
R844 VDD.t24 VDD.t236 44.1994
R845 VDD.t236 VDD.t188 44.1994
R846 VDD.t188 VDD.t522 44.1994
R847 VDD.t522 VDD.t58 44.1994
R848 VDD.t58 VDD.t586 44.1994
R849 VDD.t586 VDD.t204 44.1994
R850 VDD.t204 VDD.t280 44.1994
R851 VDD.t280 VDD.t60 44.1994
R852 VDD.t60 VDD.t90 44.1994
R853 VDD.t90 VDD.t238 44.1994
R854 VDD.t238 VDD.t150 44.1994
R855 VDD.t150 VDD.t240 44.1994
R856 VDD.t286 VDD.t564 44.1994
R857 VDD.t564 VDD.t562 44.1994
R858 VDD.t562 VDD.t530 44.1994
R859 VDD.t530 VDD.t528 44.1994
R860 VDD.t528 VDD.t284 44.1994
R861 VDD.t284 VDD.t282 44.1994
R862 VDD.t282 VDD.t506 44.1994
R863 VDD.t506 VDD.t504 44.1994
R864 VDD.t504 VDD.t494 44.1994
R865 VDD.t494 VDD.t492 44.1994
R866 VDD.t492 VDD.t290 44.1994
R867 VDD.t290 VDD.t288 44.1994
R868 VDD.t288 VDD.t568 44.1994
R869 VDD.t568 VDD.t566 44.1994
R870 VDD.t566 VDD.t534 44.1994
R871 VDD.t534 VDD.t532 44.1994
R872 VDD.t532 VDD.t388 44.1994
R873 VDD.t388 VDD.t386 44.1994
R874 VDD.t386 VDD.t514 44.1994
R875 VDD.t514 VDD.t512 44.1994
R876 VDD.t512 VDD.t498 44.1994
R877 VDD.t498 VDD.t496 44.1994
R878 VDD.t496 VDD.t396 44.1994
R879 VDD.t396 VDD.t394 44.1994
R880 VDD.t394 VDD.t572 44.1994
R881 VDD.t572 VDD.t570 44.1994
R882 VDD.t570 VDD.t538 44.1994
R883 VDD.t538 VDD.t536 44.1994
R884 VDD.t536 VDD.t392 44.1994
R885 VDD.t392 VDD.t390 44.1994
R886 VDD.t390 VDD.t510 44.1994
R887 VDD.t510 VDD.t508 44.1994
R888 VDD.t508 VDD.t502 44.1994
R889 VDD.t502 VDD.t500 44.1994
R890 VDD.t500 VDD.t400 44.1994
R891 VDD.t400 VDD.t398 44.1994
R892 VDD.t398 VDD.t136 44.1994
R893 VDD.t136 VDD.t134 44.1994
R894 VDD.t134 VDD.t158 44.1994
R895 VDD.t158 VDD.t156 44.1994
R896 VDD.t156 VDD.t64 44.1994
R897 VDD.t64 VDD.t62 44.1994
R898 VDD.t62 VDD.t8 44.1994
R899 VDD.t8 VDD.t6 44.1994
R900 VDD.t6 VDD.t140 44.1994
R901 VDD.t140 VDD.t138 44.1994
R902 VDD.t138 VDD.t162 44.1994
R903 VDD.t162 VDD.t160 44.1994
R904 VDD.t160 VDD.t68 44.1994
R905 VDD.t68 VDD.t66 44.1994
R906 VDD.t66 VDD.t12 44.1994
R907 VDD.t12 VDD.t10 44.1994
R908 VDD.t10 VDD.t144 44.1994
R909 VDD.t144 VDD.t142 44.1994
R910 VDD.t142 VDD.t166 44.1994
R911 VDD.t166 VDD.t164 44.1994
R912 VDD.t164 VDD.t72 44.1994
R913 VDD.t72 VDD.t70 44.1994
R914 VDD.t70 VDD.t16 44.1994
R915 VDD.t16 VDD.t14 44.1994
R916 VDD.t14 VDD.t148 44.1994
R917 VDD.t148 VDD.t146 44.1994
R918 VDD.t146 VDD.t168 44.1994
R919 VDD.t262 VDD.t264 44.1994
R920 VDD.t264 VDD.t270 44.1994
R921 VDD.t270 VDD.t268 44.1994
R922 VDD.t224 VDD.t226 44.1994
R923 VDD.t226 VDD.t228 44.1994
R924 VDD.t228 VDD.t230 44.1994
R925 VDD.t272 VDD.t274 44.1994
R926 VDD.t274 VDD.t260 44.1994
R927 VDD.t260 VDD.t266 44.1994
R928 VDD.t116 VDD.t580 44.1994
R929 VDD.t580 VDD.t178 44.1994
R930 VDD.t178 VDD.t246 44.1994
R931 VDD.t246 VDD.t76 44.1994
R932 VDD.t76 VDD.t206 44.1994
R933 VDD.t206 VDD.t258 44.1994
R934 VDD.t258 VDD.t128 44.1994
R935 VDD.t248 VDD.t0 44.1994
R936 VDD.t0 VDD.t574 44.1994
R937 VDD.t574 VDD.t122 44.1994
R938 VDD.t122 VDD.t114 44.1994
R939 VDD.t114 VDD.t518 44.1994
R940 VDD.t518 VDD.t22 44.1994
R941 VDD.t22 VDD.t40 44.1994
R942 VDD.t516 VDD.t294 44.1994
R943 VDD.t294 VDD.t292 44.1994
R944 VDD.t292 VDD.t38 44.1994
R945 VDD.t38 VDD.t36 44.1994
R946 VDD.t36 VDD.t34 44.1994
R947 VDD.t34 VDD.t32 44.1994
R948 VDD.t32 VDD.t296 44.1994
R949 VDD.t244 VDD.t242 44.1994
R950 VDD.t242 VDD.t112 44.1994
R951 VDD.t112 VDD.t110 44.1994
R952 VDD.t110 VDD.t578 44.1994
R953 VDD.t578 VDD.t576 44.1994
R954 VDD.t576 VDD.t154 44.1994
R955 VDD.t154 VDD.t152 44.1994
R956 VDD.t152 VDD.t256 44.1994
R957 VDD.t256 VDD.t254 44.1994
R958 VDD.t254 VDD.t526 44.1994
R959 VDD.t526 VDD.t524 44.1994
R960 VDD.t524 VDD.t126 44.1994
R961 VDD.t126 VDD.t124 44.1994
R962 VDD.t124 VDD.t590 44.1994
R963 VDD.t590 VDD.t588 44.1994
R964 VDD.t356 VDD.t360 44.1994
R965 VDD.t360 VDD.t358 44.1994
R966 VDD.t358 VDD.t364 44.1994
R967 VDD.t364 VDD.t362 44.1994
R968 VDD.t362 VDD.t556 44.1994
R969 VDD.t556 VDD.t554 44.1994
R970 VDD.t554 VDD.t552 44.1994
R971 VDD.t552 VDD.t550 44.1994
R972 VDD.t550 VDD.t304 44.1994
R973 VDD.t304 VDD.t302 44.1994
R974 VDD.t302 VDD.t320 44.1994
R975 VDD.t320 VDD.t318 44.1994
R976 VDD.t318 VDD.t312 44.1994
R977 VDD.t312 VDD.t310 44.1994
R978 VDD.t310 VDD.t328 44.1994
R979 VDD.t328 VDD.t326 44.1994
R980 VDD.t326 VDD.t368 44.1994
R981 VDD.t368 VDD.t366 44.1994
R982 VDD.t366 VDD.t372 44.1994
R983 VDD.t372 VDD.t370 44.1994
R984 VDD.t370 VDD.t334 44.1994
R985 VDD.t334 VDD.t332 44.1994
R986 VDD.t332 VDD.t330 44.1994
R987 VDD.t330 VDD.t340 44.1994
R988 VDD.t340 VDD.t338 44.1994
R989 VDD.t338 VDD.t336 44.1994
R990 VDD.t336 VDD.t346 44.1994
R991 VDD.t346 VDD.t344 44.1994
R992 VDD.t344 VDD.t342 44.1994
R993 VDD.t342 VDD.t560 44.1994
R994 VDD.t560 VDD.t558 44.1994
R995 VDD.t448 VDD.t446 44.1994
R996 VDD.t446 VDD.t452 44.1994
R997 VDD.t452 VDD.t450 44.1994
R998 VDD.t450 VDD.t456 44.1994
R999 VDD.t456 VDD.t454 44.1994
R1000 VDD.t454 VDD.t460 44.1994
R1001 VDD.t460 VDD.t458 44.1994
R1002 VDD.t458 VDD.t376 44.1994
R1003 VDD.t376 VDD.t374 44.1994
R1004 VDD.t374 VDD.t350 44.1994
R1005 VDD.t350 VDD.t348 44.1994
R1006 VDD.t348 VDD.t464 44.1994
R1007 VDD.t464 VDD.t462 44.1994
R1008 VDD.t462 VDD.t468 44.1994
R1009 VDD.t468 VDD.t466 44.1994
R1010 VDD.t466 VDD.t472 44.1994
R1011 VDD.t472 VDD.t470 44.1994
R1012 VDD.t470 VDD.t438 44.1994
R1013 VDD.t438 VDD.t436 44.1994
R1014 VDD.t436 VDD.t420 44.1994
R1015 VDD.t420 VDD.t418 44.1994
R1016 VDD.t418 VDD.t428 44.1994
R1017 VDD.t428 VDD.t426 44.1994
R1018 VDD.t426 VDD.t384 44.1994
R1019 VDD.t384 VDD.t382 44.1994
R1020 VDD.t382 VDD.t542 44.1994
R1021 VDD.t542 VDD.t540 44.1994
R1022 VDD.t540 VDD.t300 44.1994
R1023 VDD.t300 VDD.t298 44.1994
R1024 VDD.t298 VDD.t316 44.1994
R1025 VDD.t316 VDD.t314 44.1994
R1026 VDD.t314 VDD.t308 44.1994
R1027 VDD.t308 VDD.t306 44.1994
R1028 VDD.t306 VDD.t324 44.1994
R1029 VDD.t324 VDD.t322 44.1994
R1030 VDD.t322 VDD.t354 44.1994
R1031 VDD.t354 VDD.t352 44.1994
R1032 VDD.t352 VDD.t380 44.1994
R1033 VDD.t380 VDD.t378 44.1994
R1034 VDD.t378 VDD.t404 44.1994
R1035 VDD.t404 VDD.t402 44.1994
R1036 VDD.t402 VDD.t412 44.1994
R1037 VDD.t412 VDD.t410 44.1994
R1038 VDD.t410 VDD.t408 44.1994
R1039 VDD.t408 VDD.t406 44.1994
R1040 VDD.t406 VDD.t416 44.1994
R1041 VDD.t416 VDD.t414 44.1994
R1042 VDD.t414 VDD.t424 44.1994
R1043 VDD.t424 VDD.t422 44.1994
R1044 VDD.t422 VDD.t444 44.1994
R1045 VDD.t444 VDD.t442 44.1994
R1046 VDD.t442 VDD.t440 44.1994
R1047 VDD.t440 VDD.t434 44.1994
R1048 VDD.t434 VDD.t432 44.1994
R1049 VDD.t432 VDD.t430 44.1994
R1050 VDD.t430 VDD.t478 44.1994
R1051 VDD.t478 VDD.t476 44.1994
R1052 VDD.t476 VDD.t474 44.1994
R1053 VDD.t474 VDD.t484 44.1994
R1054 VDD.t484 VDD.t482 44.1994
R1055 VDD.t482 VDD.t480 44.1994
R1056 VDD.t480 VDD.t488 44.1994
R1057 VDD.t488 VDD.t486 44.1994
R1058 VDD.n244 VDD.n212 12.4837
R1059 VDD.n95 VDD.n63 12.4837
R1060 VDD.n244 VDD.n243 11.1661
R1061 VDD.n260 VDD.n259 11.1661
R1062 VDD.n268 VDD.n267 11.1661
R1063 VDD.n276 VDD.n275 11.1661
R1064 VDD.n284 VDD.n283 11.1661
R1065 VDD.n288 VDD.n287 11.1661
R1066 VDD.n292 VDD.n291 11.1661
R1067 VDD.n296 VDD.n295 11.1661
R1068 VDD.n95 VDD.n94 11.1661
R1069 VDD.n111 VDD.n110 11.1661
R1070 VDD.n119 VDD.n118 11.1661
R1071 VDD.n127 VDD.n126 11.1661
R1072 VDD.n135 VDD.n134 11.1661
R1073 VDD.n139 VDD.n138 11.1661
R1074 VDD.n143 VDD.n142 11.1661
R1075 VDD.n147 VDD.n146 11.1661
R1076 VDD.n152 VDD.n150 5.51014
R1077 VDD.n215 VDD.n213 5.51014
R1078 VDD.n247 VDD.n245 5.51014
R1079 VDD.n263 VDD.n261 5.51014
R1080 VDD.n271 VDD.n269 5.51014
R1081 VDD.n279 VDD.n277 5.51014
R1082 VDD.n287 VDD.n285 5.51014
R1083 VDD.n291 VDD.n289 5.51014
R1084 VDD.n295 VDD.n293 5.51014
R1085 VDD.n3 VDD.n1 5.51014
R1086 VDD.n66 VDD.n64 5.51014
R1087 VDD.n98 VDD.n96 5.51014
R1088 VDD.n114 VDD.n112 5.51014
R1089 VDD.n122 VDD.n120 5.51014
R1090 VDD.n130 VDD.n128 5.51014
R1091 VDD.n138 VDD.n136 5.51014
R1092 VDD.n142 VDD.n140 5.51014
R1093 VDD.n146 VDD.n144 5.51014
R1094 VDD.n212 VDD.n211 5.32067
R1095 VDD.n210 VDD.n209 5.32067
R1096 VDD.n208 VDD.n207 5.32067
R1097 VDD.n206 VDD.n205 5.32067
R1098 VDD.n204 VDD.n203 5.32067
R1099 VDD.n202 VDD.n201 5.32067
R1100 VDD.n200 VDD.n199 5.32067
R1101 VDD.n198 VDD.n197 5.32067
R1102 VDD.n196 VDD.n195 5.32067
R1103 VDD.n194 VDD.n193 5.32067
R1104 VDD.n192 VDD.n191 5.32067
R1105 VDD.n190 VDD.n189 5.32067
R1106 VDD.n188 VDD.n187 5.32067
R1107 VDD.n186 VDD.n185 5.32067
R1108 VDD.n184 VDD.n183 5.32067
R1109 VDD.n182 VDD.n181 5.32067
R1110 VDD.n180 VDD.n179 5.32067
R1111 VDD.n178 VDD.n177 5.32067
R1112 VDD.n176 VDD.n175 5.32067
R1113 VDD.n174 VDD.n173 5.32067
R1114 VDD.n172 VDD.n171 5.32067
R1115 VDD.n170 VDD.n169 5.32067
R1116 VDD.n168 VDD.n167 5.32067
R1117 VDD.n166 VDD.n165 5.32067
R1118 VDD.n164 VDD.n163 5.32067
R1119 VDD.n162 VDD.n161 5.32067
R1120 VDD.n160 VDD.n159 5.32067
R1121 VDD.n158 VDD.n157 5.32067
R1122 VDD.n156 VDD.n155 5.32067
R1123 VDD.n154 VDD.n153 5.32067
R1124 VDD.n152 VDD.n151 5.32067
R1125 VDD.n243 VDD.n242 5.32067
R1126 VDD.n241 VDD.n240 5.32067
R1127 VDD.n239 VDD.n238 5.32067
R1128 VDD.n237 VDD.n236 5.32067
R1129 VDD.n235 VDD.n234 5.32067
R1130 VDD.n233 VDD.n232 5.32067
R1131 VDD.n231 VDD.n230 5.32067
R1132 VDD.n229 VDD.n228 5.32067
R1133 VDD.n227 VDD.n226 5.32067
R1134 VDD.n225 VDD.n224 5.32067
R1135 VDD.n223 VDD.n222 5.32067
R1136 VDD.n221 VDD.n220 5.32067
R1137 VDD.n219 VDD.n218 5.32067
R1138 VDD.n217 VDD.n216 5.32067
R1139 VDD.n215 VDD.n214 5.32067
R1140 VDD.n259 VDD.n258 5.32067
R1141 VDD.n257 VDD.n256 5.32067
R1142 VDD.n255 VDD.n254 5.32067
R1143 VDD.n253 VDD.n252 5.32067
R1144 VDD.n251 VDD.n250 5.32067
R1145 VDD.n249 VDD.n248 5.32067
R1146 VDD.n247 VDD.n246 5.32067
R1147 VDD.n267 VDD.n266 5.32067
R1148 VDD.n265 VDD.n264 5.32067
R1149 VDD.n263 VDD.n262 5.32067
R1150 VDD.n275 VDD.n274 5.32067
R1151 VDD.n273 VDD.n272 5.32067
R1152 VDD.n271 VDD.n270 5.32067
R1153 VDD.n283 VDD.n282 5.32067
R1154 VDD.n281 VDD.n280 5.32067
R1155 VDD.n279 VDD.n278 5.32067
R1156 VDD.n287 VDD.n286 5.32067
R1157 VDD.n291 VDD.n290 5.32067
R1158 VDD.n295 VDD.n294 5.32067
R1159 VDD.n63 VDD.n62 5.32067
R1160 VDD.n61 VDD.n60 5.32067
R1161 VDD.n59 VDD.n58 5.32067
R1162 VDD.n57 VDD.n56 5.32067
R1163 VDD.n55 VDD.n54 5.32067
R1164 VDD.n53 VDD.n52 5.32067
R1165 VDD.n51 VDD.n50 5.32067
R1166 VDD.n49 VDD.n48 5.32067
R1167 VDD.n47 VDD.n46 5.32067
R1168 VDD.n45 VDD.n44 5.32067
R1169 VDD.n43 VDD.n42 5.32067
R1170 VDD.n41 VDD.n40 5.32067
R1171 VDD.n39 VDD.n38 5.32067
R1172 VDD.n37 VDD.n36 5.32067
R1173 VDD.n35 VDD.n34 5.32067
R1174 VDD.n33 VDD.n32 5.32067
R1175 VDD.n31 VDD.n30 5.32067
R1176 VDD.n29 VDD.n28 5.32067
R1177 VDD.n27 VDD.n26 5.32067
R1178 VDD.n25 VDD.n24 5.32067
R1179 VDD.n23 VDD.n22 5.32067
R1180 VDD.n21 VDD.n20 5.32067
R1181 VDD.n19 VDD.n18 5.32067
R1182 VDD.n17 VDD.n16 5.32067
R1183 VDD.n15 VDD.n14 5.32067
R1184 VDD.n13 VDD.n12 5.32067
R1185 VDD.n11 VDD.n10 5.32067
R1186 VDD.n9 VDD.n8 5.32067
R1187 VDD.n7 VDD.n6 5.32067
R1188 VDD.n5 VDD.n4 5.32067
R1189 VDD.n3 VDD.n2 5.32067
R1190 VDD.n94 VDD.n93 5.32067
R1191 VDD.n92 VDD.n91 5.32067
R1192 VDD.n90 VDD.n89 5.32067
R1193 VDD.n88 VDD.n87 5.32067
R1194 VDD.n86 VDD.n85 5.32067
R1195 VDD.n84 VDD.n83 5.32067
R1196 VDD.n82 VDD.n81 5.32067
R1197 VDD.n80 VDD.n79 5.32067
R1198 VDD.n78 VDD.n77 5.32067
R1199 VDD.n76 VDD.n75 5.32067
R1200 VDD.n74 VDD.n73 5.32067
R1201 VDD.n72 VDD.n71 5.32067
R1202 VDD.n70 VDD.n69 5.32067
R1203 VDD.n68 VDD.n67 5.32067
R1204 VDD.n66 VDD.n65 5.32067
R1205 VDD.n110 VDD.n109 5.32067
R1206 VDD.n108 VDD.n107 5.32067
R1207 VDD.n106 VDD.n105 5.32067
R1208 VDD.n104 VDD.n103 5.32067
R1209 VDD.n102 VDD.n101 5.32067
R1210 VDD.n100 VDD.n99 5.32067
R1211 VDD.n98 VDD.n97 5.32067
R1212 VDD.n118 VDD.n117 5.32067
R1213 VDD.n116 VDD.n115 5.32067
R1214 VDD.n114 VDD.n113 5.32067
R1215 VDD.n126 VDD.n125 5.32067
R1216 VDD.n124 VDD.n123 5.32067
R1217 VDD.n122 VDD.n121 5.32067
R1218 VDD.n134 VDD.n133 5.32067
R1219 VDD.n132 VDD.n131 5.32067
R1220 VDD.n130 VDD.n129 5.32067
R1221 VDD.n138 VDD.n137 5.32067
R1222 VDD.n142 VDD.n141 5.32067
R1223 VDD.n146 VDD.n145 5.32067
R1224 VDD.n149 VDD.n0 4.5005
R1225 VDD.n298 VDD.n0 4.5005
R1226 VDD.n149 VDD.n148 3.31749
R1227 VDD.n298 VDD.n297 2.77651
R1228 VDD.n300 VDD.n299 2.26839
R1229 VDD VDD.n300 1.13544
R1230 VDD.n260 VDD.n244 0.7421
R1231 VDD.n111 VDD.n95 0.7421
R1232 VDD.n268 VDD.n260 0.4541
R1233 VDD.n119 VDD.n111 0.4541
R1234 VDD.n288 VDD.n284 0.3101
R1235 VDD.n284 VDD.n276 0.3101
R1236 VDD.n276 VDD.n268 0.3101
R1237 VDD.n139 VDD.n135 0.3101
R1238 VDD.n135 VDD.n127 0.3101
R1239 VDD.n127 VDD.n119 0.3101
R1240 VDD.n297 VDD.n296 0.244205
R1241 VDD.n148 VDD.n147 0.244205
R1242 VDD.n296 VDD.n292 0.2381
R1243 VDD.n292 VDD.n288 0.2381
R1244 VDD.n147 VDD.n143 0.2381
R1245 VDD.n143 VDD.n139 0.2381
R1246 VDD.n211 VDD.t147 0.228
R1247 VDD.n211 VDD.t169 0.228
R1248 VDD.n209 VDD.t15 0.228
R1249 VDD.n209 VDD.t149 0.228
R1250 VDD.n207 VDD.t71 0.228
R1251 VDD.n207 VDD.t17 0.228
R1252 VDD.n205 VDD.t165 0.228
R1253 VDD.n205 VDD.t73 0.228
R1254 VDD.n203 VDD.t143 0.228
R1255 VDD.n203 VDD.t167 0.228
R1256 VDD.n201 VDD.t11 0.228
R1257 VDD.n201 VDD.t145 0.228
R1258 VDD.n199 VDD.t67 0.228
R1259 VDD.n199 VDD.t13 0.228
R1260 VDD.n197 VDD.t161 0.228
R1261 VDD.n197 VDD.t69 0.228
R1262 VDD.n195 VDD.t139 0.228
R1263 VDD.n195 VDD.t163 0.228
R1264 VDD.n193 VDD.t7 0.228
R1265 VDD.n193 VDD.t141 0.228
R1266 VDD.n191 VDD.t63 0.228
R1267 VDD.n191 VDD.t9 0.228
R1268 VDD.n189 VDD.t157 0.228
R1269 VDD.n189 VDD.t65 0.228
R1270 VDD.n187 VDD.t135 0.228
R1271 VDD.n187 VDD.t159 0.228
R1272 VDD.n185 VDD.t399 0.228
R1273 VDD.n185 VDD.t137 0.228
R1274 VDD.n183 VDD.t501 0.228
R1275 VDD.n183 VDD.t401 0.228
R1276 VDD.n181 VDD.t509 0.228
R1277 VDD.n181 VDD.t503 0.228
R1278 VDD.n179 VDD.t391 0.228
R1279 VDD.n179 VDD.t511 0.228
R1280 VDD.n177 VDD.t537 0.228
R1281 VDD.n177 VDD.t393 0.228
R1282 VDD.n175 VDD.t571 0.228
R1283 VDD.n175 VDD.t539 0.228
R1284 VDD.n173 VDD.t395 0.228
R1285 VDD.n173 VDD.t573 0.228
R1286 VDD.n171 VDD.t497 0.228
R1287 VDD.n171 VDD.t397 0.228
R1288 VDD.n169 VDD.t513 0.228
R1289 VDD.n169 VDD.t499 0.228
R1290 VDD.n167 VDD.t387 0.228
R1291 VDD.n167 VDD.t515 0.228
R1292 VDD.n165 VDD.t533 0.228
R1293 VDD.n165 VDD.t389 0.228
R1294 VDD.n163 VDD.t567 0.228
R1295 VDD.n163 VDD.t535 0.228
R1296 VDD.n161 VDD.t289 0.228
R1297 VDD.n161 VDD.t569 0.228
R1298 VDD.n159 VDD.t493 0.228
R1299 VDD.n159 VDD.t291 0.228
R1300 VDD.n157 VDD.t505 0.228
R1301 VDD.n157 VDD.t495 0.228
R1302 VDD.n155 VDD.t283 0.228
R1303 VDD.n155 VDD.t507 0.228
R1304 VDD.n153 VDD.t529 0.228
R1305 VDD.n153 VDD.t285 0.228
R1306 VDD.n151 VDD.t563 0.228
R1307 VDD.n151 VDD.t531 0.228
R1308 VDD.n150 VDD.t287 0.228
R1309 VDD.n150 VDD.t565 0.228
R1310 VDD.n242 VDD.t151 0.228
R1311 VDD.n242 VDD.t241 0.228
R1312 VDD.n240 VDD.t91 0.228
R1313 VDD.n240 VDD.t239 0.228
R1314 VDD.n238 VDD.t281 0.228
R1315 VDD.n238 VDD.t61 0.228
R1316 VDD.n236 VDD.t587 0.228
R1317 VDD.n236 VDD.t205 0.228
R1318 VDD.n234 VDD.t523 0.228
R1319 VDD.n234 VDD.t59 0.228
R1320 VDD.n232 VDD.t237 0.228
R1321 VDD.n232 VDD.t189 0.228
R1322 VDD.n230 VDD.t87 0.228
R1323 VDD.n230 VDD.t25 0.228
R1324 VDD.n228 VDD.t105 0.228
R1325 VDD.n228 VDD.t199 0.228
R1326 VDD.n226 VDD.t181 0.228
R1327 VDD.n226 VDD.t183 0.228
R1328 VDD.n224 VDD.t101 0.228
R1329 VDD.n224 VDD.t491 0.228
R1330 VDD.n222 VDD.t107 0.228
R1331 VDD.n222 VDD.t521 0.228
R1332 VDD.n220 VDD.t109 0.228
R1333 VDD.n220 VDD.t55 0.228
R1334 VDD.n218 VDD.t583 0.228
R1335 VDD.n218 VDD.t103 0.228
R1336 VDD.n216 VDD.t29 0.228
R1337 VDD.n216 VDD.t31 0.228
R1338 VDD.n214 VDD.t57 0.228
R1339 VDD.n214 VDD.t53 0.228
R1340 VDD.n213 VDD.t545 0.228
R1341 VDD.n213 VDD.t89 0.228
R1342 VDD.n258 VDD.t133 0.228
R1343 VDD.n258 VDD.t131 0.228
R1344 VDD.n256 VDD.t193 0.228
R1345 VDD.n256 VDD.t191 0.228
R1346 VDD.n254 VDD.t45 0.228
R1347 VDD.n254 VDD.t43 0.228
R1348 VDD.n252 VDD.t81 0.228
R1349 VDD.n252 VDD.t79 0.228
R1350 VDD.n250 VDD.t95 0.228
R1351 VDD.n250 VDD.t93 0.228
R1352 VDD.n248 VDD.t5 0.228
R1353 VDD.n248 VDD.t3 0.228
R1354 VDD.n246 VDD.t187 0.228
R1355 VDD.n246 VDD.t185 0.228
R1356 VDD.n245 VDD.t279 0.228
R1357 VDD.n245 VDD.t277 0.228
R1358 VDD.n266 VDD.t197 0.228
R1359 VDD.n266 VDD.t195 0.228
R1360 VDD.n264 VDD.t121 0.228
R1361 VDD.n264 VDD.t119 0.228
R1362 VDD.n262 VDD.t49 0.228
R1363 VDD.n262 VDD.t47 0.228
R1364 VDD.n261 VDD.t21 0.228
R1365 VDD.n261 VDD.t19 0.228
R1366 VDD.n274 VDD.t83 0.228
R1367 VDD.n274 VDD.t51 0.228
R1368 VDD.n272 VDD.t97 0.228
R1369 VDD.n272 VDD.t85 0.228
R1370 VDD.n270 VDD.t233 0.228
R1371 VDD.n270 VDD.t99 0.228
R1372 VDD.n269 VDD.t27 0.228
R1373 VDD.n269 VDD.t235 0.228
R1374 VDD.n282 VDD.t201 0.228
R1375 VDD.n282 VDD.t75 0.228
R1376 VDD.n280 VDD.t547 0.228
R1377 VDD.n280 VDD.t203 0.228
R1378 VDD.n278 VDD.t251 0.228
R1379 VDD.n278 VDD.t549 0.228
R1380 VDD.n277 VDD.t585 0.228
R1381 VDD.n277 VDD.t253 0.228
R1382 VDD.n286 VDD.t223 0.228
R1383 VDD.n286 VDD.t209 0.228
R1384 VDD.n285 VDD.t213 0.228
R1385 VDD.n285 VDD.t211 0.228
R1386 VDD.n290 VDD.t175 0.228
R1387 VDD.n290 VDD.t177 0.228
R1388 VDD.n289 VDD.t171 0.228
R1389 VDD.n289 VDD.t173 0.228
R1390 VDD.n294 VDD.t215 0.228
R1391 VDD.n294 VDD.t221 0.228
R1392 VDD.n293 VDD.t219 0.228
R1393 VDD.n293 VDD.t217 0.228
R1394 VDD.n62 VDD.t489 0.228
R1395 VDD.n62 VDD.t487 0.228
R1396 VDD.n60 VDD.t483 0.228
R1397 VDD.n60 VDD.t481 0.228
R1398 VDD.n58 VDD.t475 0.228
R1399 VDD.n58 VDD.t485 0.228
R1400 VDD.n56 VDD.t479 0.228
R1401 VDD.n56 VDD.t477 0.228
R1402 VDD.n54 VDD.t433 0.228
R1403 VDD.n54 VDD.t431 0.228
R1404 VDD.n52 VDD.t441 0.228
R1405 VDD.n52 VDD.t435 0.228
R1406 VDD.n50 VDD.t445 0.228
R1407 VDD.n50 VDD.t443 0.228
R1408 VDD.n48 VDD.t425 0.228
R1409 VDD.n48 VDD.t423 0.228
R1410 VDD.n46 VDD.t417 0.228
R1411 VDD.n46 VDD.t415 0.228
R1412 VDD.n44 VDD.t409 0.228
R1413 VDD.n44 VDD.t407 0.228
R1414 VDD.n42 VDD.t413 0.228
R1415 VDD.n42 VDD.t411 0.228
R1416 VDD.n40 VDD.t405 0.228
R1417 VDD.n40 VDD.t403 0.228
R1418 VDD.n38 VDD.t381 0.228
R1419 VDD.n38 VDD.t379 0.228
R1420 VDD.n36 VDD.t355 0.228
R1421 VDD.n36 VDD.t353 0.228
R1422 VDD.n34 VDD.t325 0.228
R1423 VDD.n34 VDD.t323 0.228
R1424 VDD.n32 VDD.t309 0.228
R1425 VDD.n32 VDD.t307 0.228
R1426 VDD.n30 VDD.t317 0.228
R1427 VDD.n30 VDD.t315 0.228
R1428 VDD.n28 VDD.t301 0.228
R1429 VDD.n28 VDD.t299 0.228
R1430 VDD.n26 VDD.t543 0.228
R1431 VDD.n26 VDD.t541 0.228
R1432 VDD.n24 VDD.t385 0.228
R1433 VDD.n24 VDD.t383 0.228
R1434 VDD.n22 VDD.t429 0.228
R1435 VDD.n22 VDD.t427 0.228
R1436 VDD.n20 VDD.t421 0.228
R1437 VDD.n20 VDD.t419 0.228
R1438 VDD.n18 VDD.t439 0.228
R1439 VDD.n18 VDD.t437 0.228
R1440 VDD.n16 VDD.t473 0.228
R1441 VDD.n16 VDD.t471 0.228
R1442 VDD.n14 VDD.t469 0.228
R1443 VDD.n14 VDD.t467 0.228
R1444 VDD.n12 VDD.t465 0.228
R1445 VDD.n12 VDD.t463 0.228
R1446 VDD.n10 VDD.t351 0.228
R1447 VDD.n10 VDD.t349 0.228
R1448 VDD.n8 VDD.t377 0.228
R1449 VDD.n8 VDD.t375 0.228
R1450 VDD.n6 VDD.t461 0.228
R1451 VDD.n6 VDD.t459 0.228
R1452 VDD.n4 VDD.t457 0.228
R1453 VDD.n4 VDD.t455 0.228
R1454 VDD.n2 VDD.t453 0.228
R1455 VDD.n2 VDD.t451 0.228
R1456 VDD.n1 VDD.t449 0.228
R1457 VDD.n1 VDD.t447 0.228
R1458 VDD.n93 VDD.t561 0.228
R1459 VDD.n93 VDD.t559 0.228
R1460 VDD.n91 VDD.t345 0.228
R1461 VDD.n91 VDD.t343 0.228
R1462 VDD.n89 VDD.t337 0.228
R1463 VDD.n89 VDD.t347 0.228
R1464 VDD.n87 VDD.t341 0.228
R1465 VDD.n87 VDD.t339 0.228
R1466 VDD.n85 VDD.t333 0.228
R1467 VDD.n85 VDD.t331 0.228
R1468 VDD.n83 VDD.t371 0.228
R1469 VDD.n83 VDD.t335 0.228
R1470 VDD.n81 VDD.t367 0.228
R1471 VDD.n81 VDD.t373 0.228
R1472 VDD.n79 VDD.t327 0.228
R1473 VDD.n79 VDD.t369 0.228
R1474 VDD.n77 VDD.t311 0.228
R1475 VDD.n77 VDD.t329 0.228
R1476 VDD.n75 VDD.t319 0.228
R1477 VDD.n75 VDD.t313 0.228
R1478 VDD.n73 VDD.t303 0.228
R1479 VDD.n73 VDD.t321 0.228
R1480 VDD.n71 VDD.t551 0.228
R1481 VDD.n71 VDD.t305 0.228
R1482 VDD.n69 VDD.t555 0.228
R1483 VDD.n69 VDD.t553 0.228
R1484 VDD.n67 VDD.t363 0.228
R1485 VDD.n67 VDD.t557 0.228
R1486 VDD.n65 VDD.t359 0.228
R1487 VDD.n65 VDD.t365 0.228
R1488 VDD.n64 VDD.t357 0.228
R1489 VDD.n64 VDD.t361 0.228
R1490 VDD.n109 VDD.t591 0.228
R1491 VDD.n109 VDD.t589 0.228
R1492 VDD.n107 VDD.t127 0.228
R1493 VDD.n107 VDD.t125 0.228
R1494 VDD.n105 VDD.t527 0.228
R1495 VDD.n105 VDD.t525 0.228
R1496 VDD.n103 VDD.t257 0.228
R1497 VDD.n103 VDD.t255 0.228
R1498 VDD.n101 VDD.t155 0.228
R1499 VDD.n101 VDD.t153 0.228
R1500 VDD.n99 VDD.t579 0.228
R1501 VDD.n99 VDD.t577 0.228
R1502 VDD.n97 VDD.t113 0.228
R1503 VDD.n97 VDD.t111 0.228
R1504 VDD.n96 VDD.t245 0.228
R1505 VDD.n96 VDD.t243 0.228
R1506 VDD.n117 VDD.t33 0.228
R1507 VDD.n117 VDD.t297 0.228
R1508 VDD.n115 VDD.t37 0.228
R1509 VDD.n115 VDD.t35 0.228
R1510 VDD.n113 VDD.t293 0.228
R1511 VDD.n113 VDD.t39 0.228
R1512 VDD.n112 VDD.t517 0.228
R1513 VDD.n112 VDD.t295 0.228
R1514 VDD.n125 VDD.t23 0.228
R1515 VDD.n125 VDD.t41 0.228
R1516 VDD.n123 VDD.t115 0.228
R1517 VDD.n123 VDD.t519 0.228
R1518 VDD.n121 VDD.t575 0.228
R1519 VDD.n121 VDD.t123 0.228
R1520 VDD.n120 VDD.t249 0.228
R1521 VDD.n120 VDD.t1 0.228
R1522 VDD.n133 VDD.t259 0.228
R1523 VDD.n133 VDD.t129 0.228
R1524 VDD.n131 VDD.t77 0.228
R1525 VDD.n131 VDD.t207 0.228
R1526 VDD.n129 VDD.t179 0.228
R1527 VDD.n129 VDD.t247 0.228
R1528 VDD.n128 VDD.t117 0.228
R1529 VDD.n128 VDD.t581 0.228
R1530 VDD.n137 VDD.t261 0.228
R1531 VDD.n137 VDD.t267 0.228
R1532 VDD.n136 VDD.t273 0.228
R1533 VDD.n136 VDD.t275 0.228
R1534 VDD.n141 VDD.t229 0.228
R1535 VDD.n141 VDD.t231 0.228
R1536 VDD.n140 VDD.t225 0.228
R1537 VDD.n140 VDD.t227 0.228
R1538 VDD.n145 VDD.t271 0.228
R1539 VDD.n145 VDD.t269 0.228
R1540 VDD.n144 VDD.t263 0.228
R1541 VDD.n144 VDD.t265 0.228
R1542 VDD.n154 VDD.n152 0.189974
R1543 VDD.n156 VDD.n154 0.189974
R1544 VDD.n158 VDD.n156 0.189974
R1545 VDD.n160 VDD.n158 0.189974
R1546 VDD.n162 VDD.n160 0.189974
R1547 VDD.n164 VDD.n162 0.189974
R1548 VDD.n166 VDD.n164 0.189974
R1549 VDD.n168 VDD.n166 0.189974
R1550 VDD.n170 VDD.n168 0.189974
R1551 VDD.n172 VDD.n170 0.189974
R1552 VDD.n174 VDD.n172 0.189974
R1553 VDD.n176 VDD.n174 0.189974
R1554 VDD.n178 VDD.n176 0.189974
R1555 VDD.n180 VDD.n178 0.189974
R1556 VDD.n182 VDD.n180 0.189974
R1557 VDD.n184 VDD.n182 0.189974
R1558 VDD.n186 VDD.n184 0.189974
R1559 VDD.n188 VDD.n186 0.189974
R1560 VDD.n190 VDD.n188 0.189974
R1561 VDD.n192 VDD.n190 0.189974
R1562 VDD.n194 VDD.n192 0.189974
R1563 VDD.n196 VDD.n194 0.189974
R1564 VDD.n198 VDD.n196 0.189974
R1565 VDD.n200 VDD.n198 0.189974
R1566 VDD.n202 VDD.n200 0.189974
R1567 VDD.n204 VDD.n202 0.189974
R1568 VDD.n206 VDD.n204 0.189974
R1569 VDD.n208 VDD.n206 0.189974
R1570 VDD.n210 VDD.n208 0.189974
R1571 VDD.n212 VDD.n210 0.189974
R1572 VDD.n217 VDD.n215 0.189974
R1573 VDD.n219 VDD.n217 0.189974
R1574 VDD.n221 VDD.n219 0.189974
R1575 VDD.n223 VDD.n221 0.189974
R1576 VDD.n225 VDD.n223 0.189974
R1577 VDD.n227 VDD.n225 0.189974
R1578 VDD.n229 VDD.n227 0.189974
R1579 VDD.n231 VDD.n229 0.189974
R1580 VDD.n233 VDD.n231 0.189974
R1581 VDD.n235 VDD.n233 0.189974
R1582 VDD.n237 VDD.n235 0.189974
R1583 VDD.n239 VDD.n237 0.189974
R1584 VDD.n241 VDD.n239 0.189974
R1585 VDD.n243 VDD.n241 0.189974
R1586 VDD.n249 VDD.n247 0.189974
R1587 VDD.n251 VDD.n249 0.189974
R1588 VDD.n253 VDD.n251 0.189974
R1589 VDD.n255 VDD.n253 0.189974
R1590 VDD.n257 VDD.n255 0.189974
R1591 VDD.n259 VDD.n257 0.189974
R1592 VDD.n265 VDD.n263 0.189974
R1593 VDD.n267 VDD.n265 0.189974
R1594 VDD.n273 VDD.n271 0.189974
R1595 VDD.n275 VDD.n273 0.189974
R1596 VDD.n281 VDD.n279 0.189974
R1597 VDD.n283 VDD.n281 0.189974
R1598 VDD.n5 VDD.n3 0.189974
R1599 VDD.n7 VDD.n5 0.189974
R1600 VDD.n9 VDD.n7 0.189974
R1601 VDD.n11 VDD.n9 0.189974
R1602 VDD.n13 VDD.n11 0.189974
R1603 VDD.n15 VDD.n13 0.189974
R1604 VDD.n17 VDD.n15 0.189974
R1605 VDD.n19 VDD.n17 0.189974
R1606 VDD.n21 VDD.n19 0.189974
R1607 VDD.n23 VDD.n21 0.189974
R1608 VDD.n25 VDD.n23 0.189974
R1609 VDD.n27 VDD.n25 0.189974
R1610 VDD.n29 VDD.n27 0.189974
R1611 VDD.n31 VDD.n29 0.189974
R1612 VDD.n33 VDD.n31 0.189974
R1613 VDD.n35 VDD.n33 0.189974
R1614 VDD.n37 VDD.n35 0.189974
R1615 VDD.n39 VDD.n37 0.189974
R1616 VDD.n41 VDD.n39 0.189974
R1617 VDD.n43 VDD.n41 0.189974
R1618 VDD.n45 VDD.n43 0.189974
R1619 VDD.n47 VDD.n45 0.189974
R1620 VDD.n49 VDD.n47 0.189974
R1621 VDD.n51 VDD.n49 0.189974
R1622 VDD.n53 VDD.n51 0.189974
R1623 VDD.n55 VDD.n53 0.189974
R1624 VDD.n57 VDD.n55 0.189974
R1625 VDD.n59 VDD.n57 0.189974
R1626 VDD.n61 VDD.n59 0.189974
R1627 VDD.n63 VDD.n61 0.189974
R1628 VDD.n68 VDD.n66 0.189974
R1629 VDD.n70 VDD.n68 0.189974
R1630 VDD.n72 VDD.n70 0.189974
R1631 VDD.n74 VDD.n72 0.189974
R1632 VDD.n76 VDD.n74 0.189974
R1633 VDD.n78 VDD.n76 0.189974
R1634 VDD.n80 VDD.n78 0.189974
R1635 VDD.n82 VDD.n80 0.189974
R1636 VDD.n84 VDD.n82 0.189974
R1637 VDD.n86 VDD.n84 0.189974
R1638 VDD.n88 VDD.n86 0.189974
R1639 VDD.n90 VDD.n88 0.189974
R1640 VDD.n92 VDD.n90 0.189974
R1641 VDD.n94 VDD.n92 0.189974
R1642 VDD.n100 VDD.n98 0.189974
R1643 VDD.n102 VDD.n100 0.189974
R1644 VDD.n104 VDD.n102 0.189974
R1645 VDD.n106 VDD.n104 0.189974
R1646 VDD.n108 VDD.n106 0.189974
R1647 VDD.n110 VDD.n108 0.189974
R1648 VDD.n116 VDD.n114 0.189974
R1649 VDD.n118 VDD.n116 0.189974
R1650 VDD.n124 VDD.n122 0.189974
R1651 VDD.n126 VDD.n124 0.189974
R1652 VDD.n132 VDD.n130 0.189974
R1653 VDD.n134 VDD.n132 0.189974
R1654 VDD.n300 VDD.n0 0.020105
R1655 VDD.n299 VDD.n298 0.0054955
R1656 VDD.n299 VDD.n149 0.0054955
R1657 VSS.n157 VSS.n156 5121.21
R1658 VSS.n307 VSS.n157 5121.21
R1659 VSS.n154 VSS.n153 4481.41
R1660 VSS.n308 VSS.n307 4318.83
R1661 VSS.n155 VSS.n154 3545.45
R1662 VSS.n156 VSS.n155 3545.45
R1663 VSS.t334 VSS.t272 1481.56
R1664 VSS.t278 VSS.t326 1481.56
R1665 VSS.t338 VSS.t58 1481.56
R1666 VSS.t156 VSS.t576 1481.56
R1667 VSS.t578 VSS.t356 1481.56
R1668 VSS.t564 VSS.t586 1481.56
R1669 VSS.t148 VSS.t566 1481.56
R1670 VSS.t516 VSS.t388 1481.56
R1671 VSS.t262 VSS.t158 1481.56
R1672 VSS.t164 VSS.t258 1481.56
R1673 VSS.t256 VSS.t72 1481.56
R1674 VSS.t320 VSS.t48 1481.56
R1675 VSS.t536 VSS.t534 1481.56
R1676 VSS.t186 VSS.t110 1481.56
R1677 VSS.t104 VSS.t102 1481.56
R1678 VSS.t582 VSS.t134 1481.56
R1679 VSS.n4 VSS.t332 1285.47
R1680 VSS.n306 VSS.t260 1285.47
R1681 VSS.n155 VSS.n3 933.951
R1682 VSS.n156 VSS.n2 933.951
R1683 VSS.n154 VSS.n4 907.822
R1684 VSS.n307 VSS.n306 907.822
R1685 VSS.n309 VSS.n157 225.442
R1686 VSS.t332 VSS.t328 145.251
R1687 VSS.t328 VSS.t330 145.251
R1688 VSS.t330 VSS.t334 145.251
R1689 VSS.t272 VSS.t274 145.251
R1690 VSS.t274 VSS.t276 145.251
R1691 VSS.t276 VSS.t278 145.251
R1692 VSS.t326 VSS.t324 145.251
R1693 VSS.t324 VSS.t336 145.251
R1694 VSS.t336 VSS.t338 145.251
R1695 VSS.t58 VSS.t294 145.251
R1696 VSS.t294 VSS.t34 145.251
R1697 VSS.t34 VSS.t322 145.251
R1698 VSS.t322 VSS.t584 145.251
R1699 VSS.t584 VSS.t550 145.251
R1700 VSS.t550 VSS.t154 145.251
R1701 VSS.t154 VSS.t156 145.251
R1702 VSS.t576 VSS.t166 145.251
R1703 VSS.t166 VSS.t0 145.251
R1704 VSS.t0 VSS.t74 145.251
R1705 VSS.t74 VSS.t168 145.251
R1706 VSS.t168 VSS.t208 145.251
R1707 VSS.t208 VSS.t580 145.251
R1708 VSS.t580 VSS.t578 145.251
R1709 VSS.t356 VSS.t562 145.251
R1710 VSS.t562 VSS.t560 145.251
R1711 VSS.t560 VSS.t574 145.251
R1712 VSS.t574 VSS.t572 145.251
R1713 VSS.t572 VSS.t570 145.251
R1714 VSS.t570 VSS.t568 145.251
R1715 VSS.t568 VSS.t564 145.251
R1716 VSS.t586 VSS.t548 145.251
R1717 VSS.t548 VSS.t546 145.251
R1718 VSS.t546 VSS.t544 145.251
R1719 VSS.t544 VSS.t32 145.251
R1720 VSS.t32 VSS.t30 145.251
R1721 VSS.t30 VSS.t28 145.251
R1722 VSS.t28 VSS.t80 145.251
R1723 VSS.t80 VSS.t78 145.251
R1724 VSS.t78 VSS.t76 145.251
R1725 VSS.t76 VSS.t312 145.251
R1726 VSS.t312 VSS.t310 145.251
R1727 VSS.t310 VSS.t308 145.251
R1728 VSS.t308 VSS.t152 145.251
R1729 VSS.t152 VSS.t150 145.251
R1730 VSS.t150 VSS.t148 145.251
R1731 VSS.t566 VSS.t558 145.251
R1732 VSS.t558 VSS.t556 145.251
R1733 VSS.t556 VSS.t554 145.251
R1734 VSS.t554 VSS.t362 145.251
R1735 VSS.t362 VSS.t360 145.251
R1736 VSS.t360 VSS.t358 145.251
R1737 VSS.t358 VSS.t218 145.251
R1738 VSS.t218 VSS.t216 145.251
R1739 VSS.t216 VSS.t214 145.251
R1740 VSS.t214 VSS.t226 145.251
R1741 VSS.t226 VSS.t224 145.251
R1742 VSS.t224 VSS.t222 145.251
R1743 VSS.t222 VSS.t220 145.251
R1744 VSS.t220 VSS.t234 145.251
R1745 VSS.t234 VSS.t232 145.251
R1746 VSS.t232 VSS.t230 145.251
R1747 VSS.t230 VSS.t228 145.251
R1748 VSS.t228 VSS.t386 145.251
R1749 VSS.t386 VSS.t384 145.251
R1750 VSS.t384 VSS.t382 145.251
R1751 VSS.t382 VSS.t380 145.251
R1752 VSS.t380 VSS.t370 145.251
R1753 VSS.t370 VSS.t368 145.251
R1754 VSS.t368 VSS.t366 145.251
R1755 VSS.t366 VSS.t364 145.251
R1756 VSS.t364 VSS.t378 145.251
R1757 VSS.t378 VSS.t376 145.251
R1758 VSS.t376 VSS.t374 145.251
R1759 VSS.t374 VSS.t372 145.251
R1760 VSS.t372 VSS.t518 145.251
R1761 VSS.t518 VSS.t516 145.251
R1762 VSS.t388 VSS.t394 145.251
R1763 VSS.t394 VSS.t392 145.251
R1764 VSS.t392 VSS.t390 145.251
R1765 VSS.t390 VSS.t514 145.251
R1766 VSS.t514 VSS.t512 145.251
R1767 VSS.t512 VSS.t510 145.251
R1768 VSS.t510 VSS.t400 145.251
R1769 VSS.t400 VSS.t398 145.251
R1770 VSS.t398 VSS.t396 145.251
R1771 VSS.t396 VSS.t406 145.251
R1772 VSS.t406 VSS.t404 145.251
R1773 VSS.t404 VSS.t402 145.251
R1774 VSS.t402 VSS.t412 145.251
R1775 VSS.t412 VSS.t410 145.251
R1776 VSS.t410 VSS.t408 145.251
R1777 VSS.t408 VSS.t418 145.251
R1778 VSS.t418 VSS.t416 145.251
R1779 VSS.t416 VSS.t414 145.251
R1780 VSS.t414 VSS.t424 145.251
R1781 VSS.t424 VSS.t422 145.251
R1782 VSS.t422 VSS.t420 145.251
R1783 VSS.t420 VSS.t430 145.251
R1784 VSS.t430 VSS.t428 145.251
R1785 VSS.t428 VSS.t426 145.251
R1786 VSS.t426 VSS.t436 145.251
R1787 VSS.t436 VSS.t434 145.251
R1788 VSS.t434 VSS.t432 145.251
R1789 VSS.t432 VSS.t442 145.251
R1790 VSS.t442 VSS.t440 145.251
R1791 VSS.t440 VSS.t438 145.251
R1792 VSS.t438 VSS.t448 145.251
R1793 VSS.t448 VSS.t446 145.251
R1794 VSS.t446 VSS.t444 145.251
R1795 VSS.t444 VSS.t454 145.251
R1796 VSS.t454 VSS.t452 145.251
R1797 VSS.t452 VSS.t450 145.251
R1798 VSS.t450 VSS.t460 145.251
R1799 VSS.t460 VSS.t458 145.251
R1800 VSS.t458 VSS.t456 145.251
R1801 VSS.t456 VSS.t466 145.251
R1802 VSS.t466 VSS.t464 145.251
R1803 VSS.t464 VSS.t462 145.251
R1804 VSS.t462 VSS.t472 145.251
R1805 VSS.t472 VSS.t470 145.251
R1806 VSS.t470 VSS.t468 145.251
R1807 VSS.t468 VSS.t478 145.251
R1808 VSS.t478 VSS.t476 145.251
R1809 VSS.t476 VSS.t474 145.251
R1810 VSS.t474 VSS.t484 145.251
R1811 VSS.t484 VSS.t482 145.251
R1812 VSS.t482 VSS.t480 145.251
R1813 VSS.t480 VSS.t490 145.251
R1814 VSS.t490 VSS.t488 145.251
R1815 VSS.t488 VSS.t486 145.251
R1816 VSS.t486 VSS.t496 145.251
R1817 VSS.t496 VSS.t494 145.251
R1818 VSS.t494 VSS.t492 145.251
R1819 VSS.t492 VSS.t502 145.251
R1820 VSS.t502 VSS.t500 145.251
R1821 VSS.t500 VSS.t498 145.251
R1822 VSS.t498 VSS.t508 145.251
R1823 VSS.t508 VSS.t506 145.251
R1824 VSS.t506 VSS.t504 145.251
R1825 VSS.t260 VSS.t268 145.251
R1826 VSS.t268 VSS.t264 145.251
R1827 VSS.t264 VSS.t262 145.251
R1828 VSS.t158 VSS.t160 145.251
R1829 VSS.t160 VSS.t162 145.251
R1830 VSS.t162 VSS.t164 145.251
R1831 VSS.t258 VSS.t270 145.251
R1832 VSS.t270 VSS.t266 145.251
R1833 VSS.t266 VSS.t256 145.251
R1834 VSS.t72 VSS.t16 145.251
R1835 VSS.t16 VSS.t14 145.251
R1836 VSS.t14 VSS.t212 145.251
R1837 VSS.t212 VSS.t24 145.251
R1838 VSS.t24 VSS.t26 145.251
R1839 VSS.t26 VSS.t132 145.251
R1840 VSS.t132 VSS.t320 145.251
R1841 VSS.t48 VSS.t192 145.251
R1842 VSS.t192 VSS.t190 145.251
R1843 VSS.t190 VSS.t306 145.251
R1844 VSS.t306 VSS.t304 145.251
R1845 VSS.t304 VSS.t200 145.251
R1846 VSS.t200 VSS.t198 145.251
R1847 VSS.t198 VSS.t536 145.251
R1848 VSS.t534 VSS.t532 145.251
R1849 VSS.t532 VSS.t246 145.251
R1850 VSS.t246 VSS.t244 145.251
R1851 VSS.t244 VSS.t290 145.251
R1852 VSS.t290 VSS.t288 145.251
R1853 VSS.t288 VSS.t188 145.251
R1854 VSS.t188 VSS.t186 145.251
R1855 VSS.t110 VSS.t108 145.251
R1856 VSS.t108 VSS.t172 145.251
R1857 VSS.t172 VSS.t170 145.251
R1858 VSS.t170 VSS.t114 145.251
R1859 VSS.t114 VSS.t112 145.251
R1860 VSS.t112 VSS.t196 145.251
R1861 VSS.t196 VSS.t194 145.251
R1862 VSS.t194 VSS.t350 145.251
R1863 VSS.t350 VSS.t348 145.251
R1864 VSS.t348 VSS.t346 145.251
R1865 VSS.t346 VSS.t344 145.251
R1866 VSS.t344 VSS.t342 145.251
R1867 VSS.t342 VSS.t340 145.251
R1868 VSS.t340 VSS.t106 145.251
R1869 VSS.t106 VSS.t104 145.251
R1870 VSS.t102 VSS.t206 145.251
R1871 VSS.t206 VSS.t210 145.251
R1872 VSS.t210 VSS.t542 145.251
R1873 VSS.t542 VSS.t318 145.251
R1874 VSS.t318 VSS.t98 145.251
R1875 VSS.t98 VSS.t552 145.251
R1876 VSS.t552 VSS.t18 145.251
R1877 VSS.t18 VSS.t100 145.251
R1878 VSS.t100 VSS.t118 145.251
R1879 VSS.t118 VSS.t116 145.251
R1880 VSS.t116 VSS.t204 145.251
R1881 VSS.t204 VSS.t202 145.251
R1882 VSS.t202 VSS.t316 145.251
R1883 VSS.t316 VSS.t314 145.251
R1884 VSS.t314 VSS.t96 145.251
R1885 VSS.t96 VSS.t94 145.251
R1886 VSS.t94 VSS.t56 145.251
R1887 VSS.t56 VSS.t54 145.251
R1888 VSS.t54 VSS.t254 145.251
R1889 VSS.t254 VSS.t252 145.251
R1890 VSS.t252 VSS.t22 145.251
R1891 VSS.t22 VSS.t20 145.251
R1892 VSS.t20 VSS.t52 145.251
R1893 VSS.t52 VSS.t50 145.251
R1894 VSS.t50 VSS.t590 145.251
R1895 VSS.t590 VSS.t588 145.251
R1896 VSS.t588 VSS.t354 145.251
R1897 VSS.t354 VSS.t352 145.251
R1898 VSS.t352 VSS.t540 145.251
R1899 VSS.t540 VSS.t538 145.251
R1900 VSS.t538 VSS.t582 145.251
R1901 VSS.t134 VSS.t62 145.251
R1902 VSS.t62 VSS.t60 145.251
R1903 VSS.t60 VSS.t4 145.251
R1904 VSS.t4 VSS.t2 145.251
R1905 VSS.t2 VSS.t122 145.251
R1906 VSS.t122 VSS.t120 145.251
R1907 VSS.t120 VSS.t138 145.251
R1908 VSS.t138 VSS.t136 145.251
R1909 VSS.t136 VSS.t66 145.251
R1910 VSS.t66 VSS.t64 145.251
R1911 VSS.t64 VSS.t8 145.251
R1912 VSS.t8 VSS.t6 145.251
R1913 VSS.t6 VSS.t126 145.251
R1914 VSS.t126 VSS.t124 145.251
R1915 VSS.t124 VSS.t142 145.251
R1916 VSS.t142 VSS.t140 145.251
R1917 VSS.t140 VSS.t70 145.251
R1918 VSS.t70 VSS.t68 145.251
R1919 VSS.t68 VSS.t12 145.251
R1920 VSS.t12 VSS.t10 145.251
R1921 VSS.t10 VSS.t522 145.251
R1922 VSS.t522 VSS.t520 145.251
R1923 VSS.t520 VSS.t38 145.251
R1924 VSS.t38 VSS.t36 145.251
R1925 VSS.t36 VSS.t84 145.251
R1926 VSS.t84 VSS.t82 145.251
R1927 VSS.t82 VSS.t176 145.251
R1928 VSS.t176 VSS.t174 145.251
R1929 VSS.t174 VSS.t238 145.251
R1930 VSS.t238 VSS.t236 145.251
R1931 VSS.t236 VSS.t282 145.251
R1932 VSS.t282 VSS.t280 145.251
R1933 VSS.t280 VSS.t42 145.251
R1934 VSS.t42 VSS.t40 145.251
R1935 VSS.t40 VSS.t88 145.251
R1936 VSS.t88 VSS.t86 145.251
R1937 VSS.t86 VSS.t180 145.251
R1938 VSS.t180 VSS.t178 145.251
R1939 VSS.t178 VSS.t298 145.251
R1940 VSS.t298 VSS.t296 145.251
R1941 VSS.t296 VSS.t130 145.251
R1942 VSS.t130 VSS.t128 145.251
R1943 VSS.t128 VSS.t530 145.251
R1944 VSS.t530 VSS.t528 145.251
R1945 VSS.t528 VSS.t242 145.251
R1946 VSS.t242 VSS.t240 145.251
R1947 VSS.t240 VSS.t286 145.251
R1948 VSS.t286 VSS.t284 145.251
R1949 VSS.t284 VSS.t184 145.251
R1950 VSS.t184 VSS.t182 145.251
R1951 VSS.t182 VSS.t302 145.251
R1952 VSS.t302 VSS.t300 145.251
R1953 VSS.t300 VSS.t146 145.251
R1954 VSS.t146 VSS.t144 145.251
R1955 VSS.t144 VSS.t526 145.251
R1956 VSS.t526 VSS.t524 145.251
R1957 VSS.t524 VSS.t46 145.251
R1958 VSS.t46 VSS.t44 145.251
R1959 VSS.t44 VSS.t92 145.251
R1960 VSS.t92 VSS.t90 145.251
R1961 VSS.t90 VSS.t250 145.251
R1962 VSS.t250 VSS.t248 145.251
R1963 VSS.t248 VSS.t292 145.251
R1964 VSS.n152 VSS.n4 24.2224
R1965 VSS.n306 VSS.n305 24.2224
R1966 VSS.n99 VSS.n67 11.2944
R1967 VSS.n252 VSS.n220 11.2944
R1968 VSS.n99 VSS.n98 9.9768
R1969 VSS.n115 VSS.n114 9.9768
R1970 VSS.n123 VSS.n122 9.9768
R1971 VSS.n131 VSS.n130 9.9768
R1972 VSS.n139 VSS.n138 9.9768
R1973 VSS.n143 VSS.n142 9.9768
R1974 VSS.n147 VSS.n146 9.9768
R1975 VSS.n151 VSS.n150 9.9768
R1976 VSS.n252 VSS.n251 9.9768
R1977 VSS.n268 VSS.n267 9.9768
R1978 VSS.n276 VSS.n275 9.9768
R1979 VSS.n284 VSS.n283 9.9768
R1980 VSS.n292 VSS.n291 9.9768
R1981 VSS.n296 VSS.n295 9.9768
R1982 VSS.n300 VSS.n299 9.9768
R1983 VSS.n304 VSS.n303 9.9768
R1984 VSS.n7 VSS.n5 5.57485
R1985 VSS.n70 VSS.n68 5.57485
R1986 VSS.n102 VSS.n100 5.57485
R1987 VSS.n118 VSS.n116 5.57485
R1988 VSS.n126 VSS.n124 5.57485
R1989 VSS.n134 VSS.n132 5.57485
R1990 VSS.n142 VSS.n140 5.57485
R1991 VSS.n146 VSS.n144 5.57485
R1992 VSS.n150 VSS.n148 5.57485
R1993 VSS.n160 VSS.n158 5.57485
R1994 VSS.n223 VSS.n221 5.57485
R1995 VSS.n255 VSS.n253 5.57485
R1996 VSS.n271 VSS.n269 5.57485
R1997 VSS.n279 VSS.n277 5.57485
R1998 VSS.n287 VSS.n285 5.57485
R1999 VSS.n295 VSS.n293 5.57485
R2000 VSS.n299 VSS.n297 5.57485
R2001 VSS.n303 VSS.n301 5.57485
R2002 VSS.n67 VSS.n66 5.38537
R2003 VSS.n65 VSS.n64 5.38537
R2004 VSS.n63 VSS.n62 5.38537
R2005 VSS.n61 VSS.n60 5.38537
R2006 VSS.n59 VSS.n58 5.38537
R2007 VSS.n57 VSS.n56 5.38537
R2008 VSS.n55 VSS.n54 5.38537
R2009 VSS.n53 VSS.n52 5.38537
R2010 VSS.n51 VSS.n50 5.38537
R2011 VSS.n49 VSS.n48 5.38537
R2012 VSS.n47 VSS.n46 5.38537
R2013 VSS.n45 VSS.n44 5.38537
R2014 VSS.n43 VSS.n42 5.38537
R2015 VSS.n41 VSS.n40 5.38537
R2016 VSS.n39 VSS.n38 5.38537
R2017 VSS.n37 VSS.n36 5.38537
R2018 VSS.n35 VSS.n34 5.38537
R2019 VSS.n33 VSS.n32 5.38537
R2020 VSS.n31 VSS.n30 5.38537
R2021 VSS.n29 VSS.n28 5.38537
R2022 VSS.n27 VSS.n26 5.38537
R2023 VSS.n25 VSS.n24 5.38537
R2024 VSS.n23 VSS.n22 5.38537
R2025 VSS.n21 VSS.n20 5.38537
R2026 VSS.n19 VSS.n18 5.38537
R2027 VSS.n17 VSS.n16 5.38537
R2028 VSS.n15 VSS.n14 5.38537
R2029 VSS.n13 VSS.n12 5.38537
R2030 VSS.n11 VSS.n10 5.38537
R2031 VSS.n9 VSS.n8 5.38537
R2032 VSS.n7 VSS.n6 5.38537
R2033 VSS.n98 VSS.n97 5.38537
R2034 VSS.n96 VSS.n95 5.38537
R2035 VSS.n94 VSS.n93 5.38537
R2036 VSS.n92 VSS.n91 5.38537
R2037 VSS.n90 VSS.n89 5.38537
R2038 VSS.n88 VSS.n87 5.38537
R2039 VSS.n86 VSS.n85 5.38537
R2040 VSS.n84 VSS.n83 5.38537
R2041 VSS.n82 VSS.n81 5.38537
R2042 VSS.n80 VSS.n79 5.38537
R2043 VSS.n78 VSS.n77 5.38537
R2044 VSS.n76 VSS.n75 5.38537
R2045 VSS.n74 VSS.n73 5.38537
R2046 VSS.n72 VSS.n71 5.38537
R2047 VSS.n70 VSS.n69 5.38537
R2048 VSS.n114 VSS.n113 5.38537
R2049 VSS.n112 VSS.n111 5.38537
R2050 VSS.n110 VSS.n109 5.38537
R2051 VSS.n108 VSS.n107 5.38537
R2052 VSS.n106 VSS.n105 5.38537
R2053 VSS.n104 VSS.n103 5.38537
R2054 VSS.n102 VSS.n101 5.38537
R2055 VSS.n122 VSS.n121 5.38537
R2056 VSS.n120 VSS.n119 5.38537
R2057 VSS.n118 VSS.n117 5.38537
R2058 VSS.n130 VSS.n129 5.38537
R2059 VSS.n128 VSS.n127 5.38537
R2060 VSS.n126 VSS.n125 5.38537
R2061 VSS.n138 VSS.n137 5.38537
R2062 VSS.n136 VSS.n135 5.38537
R2063 VSS.n134 VSS.n133 5.38537
R2064 VSS.n142 VSS.n141 5.38537
R2065 VSS.n146 VSS.n145 5.38537
R2066 VSS.n150 VSS.n149 5.38537
R2067 VSS.n220 VSS.n219 5.38537
R2068 VSS.n218 VSS.n217 5.38537
R2069 VSS.n216 VSS.n215 5.38537
R2070 VSS.n214 VSS.n213 5.38537
R2071 VSS.n212 VSS.n211 5.38537
R2072 VSS.n210 VSS.n209 5.38537
R2073 VSS.n208 VSS.n207 5.38537
R2074 VSS.n206 VSS.n205 5.38537
R2075 VSS.n204 VSS.n203 5.38537
R2076 VSS.n202 VSS.n201 5.38537
R2077 VSS.n200 VSS.n199 5.38537
R2078 VSS.n198 VSS.n197 5.38537
R2079 VSS.n196 VSS.n195 5.38537
R2080 VSS.n194 VSS.n193 5.38537
R2081 VSS.n192 VSS.n191 5.38537
R2082 VSS.n190 VSS.n189 5.38537
R2083 VSS.n188 VSS.n187 5.38537
R2084 VSS.n186 VSS.n185 5.38537
R2085 VSS.n184 VSS.n183 5.38537
R2086 VSS.n182 VSS.n181 5.38537
R2087 VSS.n180 VSS.n179 5.38537
R2088 VSS.n178 VSS.n177 5.38537
R2089 VSS.n176 VSS.n175 5.38537
R2090 VSS.n174 VSS.n173 5.38537
R2091 VSS.n172 VSS.n171 5.38537
R2092 VSS.n170 VSS.n169 5.38537
R2093 VSS.n168 VSS.n167 5.38537
R2094 VSS.n166 VSS.n165 5.38537
R2095 VSS.n164 VSS.n163 5.38537
R2096 VSS.n162 VSS.n161 5.38537
R2097 VSS.n160 VSS.n159 5.38537
R2098 VSS.n251 VSS.n250 5.38537
R2099 VSS.n249 VSS.n248 5.38537
R2100 VSS.n247 VSS.n246 5.38537
R2101 VSS.n245 VSS.n244 5.38537
R2102 VSS.n243 VSS.n242 5.38537
R2103 VSS.n241 VSS.n240 5.38537
R2104 VSS.n239 VSS.n238 5.38537
R2105 VSS.n237 VSS.n236 5.38537
R2106 VSS.n235 VSS.n234 5.38537
R2107 VSS.n233 VSS.n232 5.38537
R2108 VSS.n231 VSS.n230 5.38537
R2109 VSS.n229 VSS.n228 5.38537
R2110 VSS.n227 VSS.n226 5.38537
R2111 VSS.n225 VSS.n224 5.38537
R2112 VSS.n223 VSS.n222 5.38537
R2113 VSS.n267 VSS.n266 5.38537
R2114 VSS.n265 VSS.n264 5.38537
R2115 VSS.n263 VSS.n262 5.38537
R2116 VSS.n261 VSS.n260 5.38537
R2117 VSS.n259 VSS.n258 5.38537
R2118 VSS.n257 VSS.n256 5.38537
R2119 VSS.n255 VSS.n254 5.38537
R2120 VSS.n275 VSS.n274 5.38537
R2121 VSS.n273 VSS.n272 5.38537
R2122 VSS.n271 VSS.n270 5.38537
R2123 VSS.n283 VSS.n282 5.38537
R2124 VSS.n281 VSS.n280 5.38537
R2125 VSS.n279 VSS.n278 5.38537
R2126 VSS.n291 VSS.n290 5.38537
R2127 VSS.n289 VSS.n288 5.38537
R2128 VSS.n287 VSS.n286 5.38537
R2129 VSS.n295 VSS.n294 5.38537
R2130 VSS.n299 VSS.n298 5.38537
R2131 VSS.n303 VSS.n302 5.38537
R2132 VSS.n1 VSS.n0 4.5005
R2133 VSS.n310 VSS.n0 4.5005
R2134 VSS.n312 VSS.n311 2.26839
R2135 VSS.n153 VSS.n152 1.90847
R2136 VSS.n308 VSS.n305 1.90847
R2137 VSS VSS.n312 1.13544
R2138 VSS.n115 VSS.n99 0.7421
R2139 VSS.n268 VSS.n252 0.7421
R2140 VSS.n153 VSS.n3 0.543479
R2141 VSS.n3 VSS.n2 0.543479
R2142 VSS.n309 VSS.n308 0.543479
R2143 VSS.n2 VSS.n1 0.507615
R2144 VSS.n310 VSS.n309 0.507363
R2145 VSS.n123 VSS.n115 0.4541
R2146 VSS.n276 VSS.n268 0.4541
R2147 VSS.n143 VSS.n139 0.3101
R2148 VSS.n139 VSS.n131 0.3101
R2149 VSS.n131 VSS.n123 0.3101
R2150 VSS.n296 VSS.n292 0.3101
R2151 VSS.n292 VSS.n284 0.3101
R2152 VSS.n284 VSS.n276 0.3101
R2153 VSS.n152 VSS.n151 0.244205
R2154 VSS.n305 VSS.n304 0.244205
R2155 VSS.n151 VSS.n147 0.2381
R2156 VSS.n147 VSS.n143 0.2381
R2157 VSS.n304 VSS.n300 0.2381
R2158 VSS.n300 VSS.n296 0.2381
R2159 VSS.n66 VSS.t507 0.20525
R2160 VSS.n66 VSS.t505 0.20525
R2161 VSS.n64 VSS.t499 0.20525
R2162 VSS.n64 VSS.t509 0.20525
R2163 VSS.n62 VSS.t503 0.20525
R2164 VSS.n62 VSS.t501 0.20525
R2165 VSS.n60 VSS.t495 0.20525
R2166 VSS.n60 VSS.t493 0.20525
R2167 VSS.n58 VSS.t487 0.20525
R2168 VSS.n58 VSS.t497 0.20525
R2169 VSS.n56 VSS.t491 0.20525
R2170 VSS.n56 VSS.t489 0.20525
R2171 VSS.n54 VSS.t483 0.20525
R2172 VSS.n54 VSS.t481 0.20525
R2173 VSS.n52 VSS.t475 0.20525
R2174 VSS.n52 VSS.t485 0.20525
R2175 VSS.n50 VSS.t479 0.20525
R2176 VSS.n50 VSS.t477 0.20525
R2177 VSS.n48 VSS.t471 0.20525
R2178 VSS.n48 VSS.t469 0.20525
R2179 VSS.n46 VSS.t463 0.20525
R2180 VSS.n46 VSS.t473 0.20525
R2181 VSS.n44 VSS.t467 0.20525
R2182 VSS.n44 VSS.t465 0.20525
R2183 VSS.n42 VSS.t459 0.20525
R2184 VSS.n42 VSS.t457 0.20525
R2185 VSS.n40 VSS.t451 0.20525
R2186 VSS.n40 VSS.t461 0.20525
R2187 VSS.n38 VSS.t455 0.20525
R2188 VSS.n38 VSS.t453 0.20525
R2189 VSS.n36 VSS.t447 0.20525
R2190 VSS.n36 VSS.t445 0.20525
R2191 VSS.n34 VSS.t439 0.20525
R2192 VSS.n34 VSS.t449 0.20525
R2193 VSS.n32 VSS.t443 0.20525
R2194 VSS.n32 VSS.t441 0.20525
R2195 VSS.n30 VSS.t435 0.20525
R2196 VSS.n30 VSS.t433 0.20525
R2197 VSS.n28 VSS.t427 0.20525
R2198 VSS.n28 VSS.t437 0.20525
R2199 VSS.n26 VSS.t431 0.20525
R2200 VSS.n26 VSS.t429 0.20525
R2201 VSS.n24 VSS.t423 0.20525
R2202 VSS.n24 VSS.t421 0.20525
R2203 VSS.n22 VSS.t415 0.20525
R2204 VSS.n22 VSS.t425 0.20525
R2205 VSS.n20 VSS.t419 0.20525
R2206 VSS.n20 VSS.t417 0.20525
R2207 VSS.n18 VSS.t411 0.20525
R2208 VSS.n18 VSS.t409 0.20525
R2209 VSS.n16 VSS.t403 0.20525
R2210 VSS.n16 VSS.t413 0.20525
R2211 VSS.n14 VSS.t407 0.20525
R2212 VSS.n14 VSS.t405 0.20525
R2213 VSS.n12 VSS.t399 0.20525
R2214 VSS.n12 VSS.t397 0.20525
R2215 VSS.n10 VSS.t511 0.20525
R2216 VSS.n10 VSS.t401 0.20525
R2217 VSS.n8 VSS.t515 0.20525
R2218 VSS.n8 VSS.t513 0.20525
R2219 VSS.n6 VSS.t393 0.20525
R2220 VSS.n6 VSS.t391 0.20525
R2221 VSS.n5 VSS.t389 0.20525
R2222 VSS.n5 VSS.t395 0.20525
R2223 VSS.n97 VSS.t519 0.20525
R2224 VSS.n97 VSS.t517 0.20525
R2225 VSS.n95 VSS.t375 0.20525
R2226 VSS.n95 VSS.t373 0.20525
R2227 VSS.n93 VSS.t379 0.20525
R2228 VSS.n93 VSS.t377 0.20525
R2229 VSS.n91 VSS.t367 0.20525
R2230 VSS.n91 VSS.t365 0.20525
R2231 VSS.n89 VSS.t371 0.20525
R2232 VSS.n89 VSS.t369 0.20525
R2233 VSS.n87 VSS.t383 0.20525
R2234 VSS.n87 VSS.t381 0.20525
R2235 VSS.n85 VSS.t387 0.20525
R2236 VSS.n85 VSS.t385 0.20525
R2237 VSS.n83 VSS.t231 0.20525
R2238 VSS.n83 VSS.t229 0.20525
R2239 VSS.n81 VSS.t235 0.20525
R2240 VSS.n81 VSS.t233 0.20525
R2241 VSS.n79 VSS.t223 0.20525
R2242 VSS.n79 VSS.t221 0.20525
R2243 VSS.n77 VSS.t227 0.20525
R2244 VSS.n77 VSS.t225 0.20525
R2245 VSS.n75 VSS.t217 0.20525
R2246 VSS.n75 VSS.t215 0.20525
R2247 VSS.n73 VSS.t359 0.20525
R2248 VSS.n73 VSS.t219 0.20525
R2249 VSS.n71 VSS.t363 0.20525
R2250 VSS.n71 VSS.t361 0.20525
R2251 VSS.n69 VSS.t557 0.20525
R2252 VSS.n69 VSS.t555 0.20525
R2253 VSS.n68 VSS.t567 0.20525
R2254 VSS.n68 VSS.t559 0.20525
R2255 VSS.n113 VSS.t151 0.20525
R2256 VSS.n113 VSS.t149 0.20525
R2257 VSS.n111 VSS.t309 0.20525
R2258 VSS.n111 VSS.t153 0.20525
R2259 VSS.n109 VSS.t313 0.20525
R2260 VSS.n109 VSS.t311 0.20525
R2261 VSS.n107 VSS.t79 0.20525
R2262 VSS.n107 VSS.t77 0.20525
R2263 VSS.n105 VSS.t29 0.20525
R2264 VSS.n105 VSS.t81 0.20525
R2265 VSS.n103 VSS.t33 0.20525
R2266 VSS.n103 VSS.t31 0.20525
R2267 VSS.n101 VSS.t547 0.20525
R2268 VSS.n101 VSS.t545 0.20525
R2269 VSS.n100 VSS.t587 0.20525
R2270 VSS.n100 VSS.t549 0.20525
R2271 VSS.n121 VSS.t569 0.20525
R2272 VSS.n121 VSS.t565 0.20525
R2273 VSS.n119 VSS.t573 0.20525
R2274 VSS.n119 VSS.t571 0.20525
R2275 VSS.n117 VSS.t561 0.20525
R2276 VSS.n117 VSS.t575 0.20525
R2277 VSS.n116 VSS.t357 0.20525
R2278 VSS.n116 VSS.t563 0.20525
R2279 VSS.n129 VSS.t581 0.20525
R2280 VSS.n129 VSS.t579 0.20525
R2281 VSS.n127 VSS.t169 0.20525
R2282 VSS.n127 VSS.t209 0.20525
R2283 VSS.n125 VSS.t1 0.20525
R2284 VSS.n125 VSS.t75 0.20525
R2285 VSS.n124 VSS.t577 0.20525
R2286 VSS.n124 VSS.t167 0.20525
R2287 VSS.n137 VSS.t155 0.20525
R2288 VSS.n137 VSS.t157 0.20525
R2289 VSS.n135 VSS.t585 0.20525
R2290 VSS.n135 VSS.t551 0.20525
R2291 VSS.n133 VSS.t35 0.20525
R2292 VSS.n133 VSS.t323 0.20525
R2293 VSS.n132 VSS.t59 0.20525
R2294 VSS.n132 VSS.t295 0.20525
R2295 VSS.n141 VSS.t337 0.20525
R2296 VSS.n141 VSS.t339 0.20525
R2297 VSS.n140 VSS.t327 0.20525
R2298 VSS.n140 VSS.t325 0.20525
R2299 VSS.n145 VSS.t277 0.20525
R2300 VSS.n145 VSS.t279 0.20525
R2301 VSS.n144 VSS.t273 0.20525
R2302 VSS.n144 VSS.t275 0.20525
R2303 VSS.n149 VSS.t331 0.20525
R2304 VSS.n149 VSS.t335 0.20525
R2305 VSS.n148 VSS.t333 0.20525
R2306 VSS.n148 VSS.t329 0.20525
R2307 VSS.n219 VSS.t249 0.20525
R2308 VSS.n219 VSS.t293 0.20525
R2309 VSS.n217 VSS.t91 0.20525
R2310 VSS.n217 VSS.t251 0.20525
R2311 VSS.n215 VSS.t45 0.20525
R2312 VSS.n215 VSS.t93 0.20525
R2313 VSS.n213 VSS.t525 0.20525
R2314 VSS.n213 VSS.t47 0.20525
R2315 VSS.n211 VSS.t145 0.20525
R2316 VSS.n211 VSS.t527 0.20525
R2317 VSS.n209 VSS.t301 0.20525
R2318 VSS.n209 VSS.t147 0.20525
R2319 VSS.n207 VSS.t183 0.20525
R2320 VSS.n207 VSS.t303 0.20525
R2321 VSS.n205 VSS.t285 0.20525
R2322 VSS.n205 VSS.t185 0.20525
R2323 VSS.n203 VSS.t241 0.20525
R2324 VSS.n203 VSS.t287 0.20525
R2325 VSS.n201 VSS.t529 0.20525
R2326 VSS.n201 VSS.t243 0.20525
R2327 VSS.n199 VSS.t129 0.20525
R2328 VSS.n199 VSS.t531 0.20525
R2329 VSS.n197 VSS.t297 0.20525
R2330 VSS.n197 VSS.t131 0.20525
R2331 VSS.n195 VSS.t179 0.20525
R2332 VSS.n195 VSS.t299 0.20525
R2333 VSS.n193 VSS.t87 0.20525
R2334 VSS.n193 VSS.t181 0.20525
R2335 VSS.n191 VSS.t41 0.20525
R2336 VSS.n191 VSS.t89 0.20525
R2337 VSS.n189 VSS.t281 0.20525
R2338 VSS.n189 VSS.t43 0.20525
R2339 VSS.n187 VSS.t237 0.20525
R2340 VSS.n187 VSS.t283 0.20525
R2341 VSS.n185 VSS.t175 0.20525
R2342 VSS.n185 VSS.t239 0.20525
R2343 VSS.n183 VSS.t83 0.20525
R2344 VSS.n183 VSS.t177 0.20525
R2345 VSS.n181 VSS.t37 0.20525
R2346 VSS.n181 VSS.t85 0.20525
R2347 VSS.n179 VSS.t521 0.20525
R2348 VSS.n179 VSS.t39 0.20525
R2349 VSS.n177 VSS.t11 0.20525
R2350 VSS.n177 VSS.t523 0.20525
R2351 VSS.n175 VSS.t69 0.20525
R2352 VSS.n175 VSS.t13 0.20525
R2353 VSS.n173 VSS.t141 0.20525
R2354 VSS.n173 VSS.t71 0.20525
R2355 VSS.n171 VSS.t125 0.20525
R2356 VSS.n171 VSS.t143 0.20525
R2357 VSS.n169 VSS.t7 0.20525
R2358 VSS.n169 VSS.t127 0.20525
R2359 VSS.n167 VSS.t65 0.20525
R2360 VSS.n167 VSS.t9 0.20525
R2361 VSS.n165 VSS.t137 0.20525
R2362 VSS.n165 VSS.t67 0.20525
R2363 VSS.n163 VSS.t121 0.20525
R2364 VSS.n163 VSS.t139 0.20525
R2365 VSS.n161 VSS.t3 0.20525
R2366 VSS.n161 VSS.t123 0.20525
R2367 VSS.n159 VSS.t61 0.20525
R2368 VSS.n159 VSS.t5 0.20525
R2369 VSS.n158 VSS.t135 0.20525
R2370 VSS.n158 VSS.t63 0.20525
R2371 VSS.n250 VSS.t539 0.20525
R2372 VSS.n250 VSS.t583 0.20525
R2373 VSS.n248 VSS.t353 0.20525
R2374 VSS.n248 VSS.t541 0.20525
R2375 VSS.n246 VSS.t589 0.20525
R2376 VSS.n246 VSS.t355 0.20525
R2377 VSS.n244 VSS.t51 0.20525
R2378 VSS.n244 VSS.t591 0.20525
R2379 VSS.n242 VSS.t21 0.20525
R2380 VSS.n242 VSS.t53 0.20525
R2381 VSS.n240 VSS.t253 0.20525
R2382 VSS.n240 VSS.t23 0.20525
R2383 VSS.n238 VSS.t55 0.20525
R2384 VSS.n238 VSS.t255 0.20525
R2385 VSS.n236 VSS.t95 0.20525
R2386 VSS.n236 VSS.t57 0.20525
R2387 VSS.n234 VSS.t315 0.20525
R2388 VSS.n234 VSS.t97 0.20525
R2389 VSS.n232 VSS.t203 0.20525
R2390 VSS.n232 VSS.t317 0.20525
R2391 VSS.n230 VSS.t117 0.20525
R2392 VSS.n230 VSS.t205 0.20525
R2393 VSS.n228 VSS.t101 0.20525
R2394 VSS.n228 VSS.t119 0.20525
R2395 VSS.n226 VSS.t553 0.20525
R2396 VSS.n226 VSS.t19 0.20525
R2397 VSS.n224 VSS.t319 0.20525
R2398 VSS.n224 VSS.t99 0.20525
R2399 VSS.n222 VSS.t211 0.20525
R2400 VSS.n222 VSS.t543 0.20525
R2401 VSS.n221 VSS.t103 0.20525
R2402 VSS.n221 VSS.t207 0.20525
R2403 VSS.n266 VSS.t107 0.20525
R2404 VSS.n266 VSS.t105 0.20525
R2405 VSS.n264 VSS.t343 0.20525
R2406 VSS.n264 VSS.t341 0.20525
R2407 VSS.n262 VSS.t347 0.20525
R2408 VSS.n262 VSS.t345 0.20525
R2409 VSS.n260 VSS.t351 0.20525
R2410 VSS.n260 VSS.t349 0.20525
R2411 VSS.n258 VSS.t197 0.20525
R2412 VSS.n258 VSS.t195 0.20525
R2413 VSS.n256 VSS.t115 0.20525
R2414 VSS.n256 VSS.t113 0.20525
R2415 VSS.n254 VSS.t173 0.20525
R2416 VSS.n254 VSS.t171 0.20525
R2417 VSS.n253 VSS.t111 0.20525
R2418 VSS.n253 VSS.t109 0.20525
R2419 VSS.n274 VSS.t189 0.20525
R2420 VSS.n274 VSS.t187 0.20525
R2421 VSS.n272 VSS.t291 0.20525
R2422 VSS.n272 VSS.t289 0.20525
R2423 VSS.n270 VSS.t247 0.20525
R2424 VSS.n270 VSS.t245 0.20525
R2425 VSS.n269 VSS.t535 0.20525
R2426 VSS.n269 VSS.t533 0.20525
R2427 VSS.n282 VSS.t199 0.20525
R2428 VSS.n282 VSS.t537 0.20525
R2429 VSS.n280 VSS.t305 0.20525
R2430 VSS.n280 VSS.t201 0.20525
R2431 VSS.n278 VSS.t191 0.20525
R2432 VSS.n278 VSS.t307 0.20525
R2433 VSS.n277 VSS.t49 0.20525
R2434 VSS.n277 VSS.t193 0.20525
R2435 VSS.n290 VSS.t133 0.20525
R2436 VSS.n290 VSS.t321 0.20525
R2437 VSS.n288 VSS.t25 0.20525
R2438 VSS.n288 VSS.t27 0.20525
R2439 VSS.n286 VSS.t15 0.20525
R2440 VSS.n286 VSS.t213 0.20525
R2441 VSS.n285 VSS.t73 0.20525
R2442 VSS.n285 VSS.t17 0.20525
R2443 VSS.n294 VSS.t267 0.20525
R2444 VSS.n294 VSS.t257 0.20525
R2445 VSS.n293 VSS.t259 0.20525
R2446 VSS.n293 VSS.t271 0.20525
R2447 VSS.n298 VSS.t163 0.20525
R2448 VSS.n298 VSS.t165 0.20525
R2449 VSS.n297 VSS.t159 0.20525
R2450 VSS.n297 VSS.t161 0.20525
R2451 VSS.n302 VSS.t265 0.20525
R2452 VSS.n302 VSS.t263 0.20525
R2453 VSS.n301 VSS.t261 0.20525
R2454 VSS.n301 VSS.t269 0.20525
R2455 VSS.n9 VSS.n7 0.189974
R2456 VSS.n11 VSS.n9 0.189974
R2457 VSS.n13 VSS.n11 0.189974
R2458 VSS.n15 VSS.n13 0.189974
R2459 VSS.n17 VSS.n15 0.189974
R2460 VSS.n19 VSS.n17 0.189974
R2461 VSS.n21 VSS.n19 0.189974
R2462 VSS.n23 VSS.n21 0.189974
R2463 VSS.n25 VSS.n23 0.189974
R2464 VSS.n27 VSS.n25 0.189974
R2465 VSS.n29 VSS.n27 0.189974
R2466 VSS.n31 VSS.n29 0.189974
R2467 VSS.n33 VSS.n31 0.189974
R2468 VSS.n35 VSS.n33 0.189974
R2469 VSS.n37 VSS.n35 0.189974
R2470 VSS.n39 VSS.n37 0.189974
R2471 VSS.n41 VSS.n39 0.189974
R2472 VSS.n43 VSS.n41 0.189974
R2473 VSS.n45 VSS.n43 0.189974
R2474 VSS.n47 VSS.n45 0.189974
R2475 VSS.n49 VSS.n47 0.189974
R2476 VSS.n51 VSS.n49 0.189974
R2477 VSS.n53 VSS.n51 0.189974
R2478 VSS.n55 VSS.n53 0.189974
R2479 VSS.n57 VSS.n55 0.189974
R2480 VSS.n59 VSS.n57 0.189974
R2481 VSS.n61 VSS.n59 0.189974
R2482 VSS.n63 VSS.n61 0.189974
R2483 VSS.n65 VSS.n63 0.189974
R2484 VSS.n67 VSS.n65 0.189974
R2485 VSS.n72 VSS.n70 0.189974
R2486 VSS.n74 VSS.n72 0.189974
R2487 VSS.n76 VSS.n74 0.189974
R2488 VSS.n78 VSS.n76 0.189974
R2489 VSS.n80 VSS.n78 0.189974
R2490 VSS.n82 VSS.n80 0.189974
R2491 VSS.n84 VSS.n82 0.189974
R2492 VSS.n86 VSS.n84 0.189974
R2493 VSS.n88 VSS.n86 0.189974
R2494 VSS.n90 VSS.n88 0.189974
R2495 VSS.n92 VSS.n90 0.189974
R2496 VSS.n94 VSS.n92 0.189974
R2497 VSS.n96 VSS.n94 0.189974
R2498 VSS.n98 VSS.n96 0.189974
R2499 VSS.n104 VSS.n102 0.189974
R2500 VSS.n106 VSS.n104 0.189974
R2501 VSS.n108 VSS.n106 0.189974
R2502 VSS.n110 VSS.n108 0.189974
R2503 VSS.n112 VSS.n110 0.189974
R2504 VSS.n114 VSS.n112 0.189974
R2505 VSS.n120 VSS.n118 0.189974
R2506 VSS.n122 VSS.n120 0.189974
R2507 VSS.n128 VSS.n126 0.189974
R2508 VSS.n130 VSS.n128 0.189974
R2509 VSS.n136 VSS.n134 0.189974
R2510 VSS.n138 VSS.n136 0.189974
R2511 VSS.n162 VSS.n160 0.189974
R2512 VSS.n164 VSS.n162 0.189974
R2513 VSS.n166 VSS.n164 0.189974
R2514 VSS.n168 VSS.n166 0.189974
R2515 VSS.n170 VSS.n168 0.189974
R2516 VSS.n172 VSS.n170 0.189974
R2517 VSS.n174 VSS.n172 0.189974
R2518 VSS.n176 VSS.n174 0.189974
R2519 VSS.n178 VSS.n176 0.189974
R2520 VSS.n180 VSS.n178 0.189974
R2521 VSS.n182 VSS.n180 0.189974
R2522 VSS.n184 VSS.n182 0.189974
R2523 VSS.n186 VSS.n184 0.189974
R2524 VSS.n188 VSS.n186 0.189974
R2525 VSS.n190 VSS.n188 0.189974
R2526 VSS.n192 VSS.n190 0.189974
R2527 VSS.n194 VSS.n192 0.189974
R2528 VSS.n196 VSS.n194 0.189974
R2529 VSS.n198 VSS.n196 0.189974
R2530 VSS.n200 VSS.n198 0.189974
R2531 VSS.n202 VSS.n200 0.189974
R2532 VSS.n204 VSS.n202 0.189974
R2533 VSS.n206 VSS.n204 0.189974
R2534 VSS.n208 VSS.n206 0.189974
R2535 VSS.n210 VSS.n208 0.189974
R2536 VSS.n212 VSS.n210 0.189974
R2537 VSS.n214 VSS.n212 0.189974
R2538 VSS.n216 VSS.n214 0.189974
R2539 VSS.n218 VSS.n216 0.189974
R2540 VSS.n220 VSS.n218 0.189974
R2541 VSS.n225 VSS.n223 0.189974
R2542 VSS.n227 VSS.n225 0.189974
R2543 VSS.n229 VSS.n227 0.189974
R2544 VSS.n231 VSS.n229 0.189974
R2545 VSS.n233 VSS.n231 0.189974
R2546 VSS.n235 VSS.n233 0.189974
R2547 VSS.n237 VSS.n235 0.189974
R2548 VSS.n239 VSS.n237 0.189974
R2549 VSS.n241 VSS.n239 0.189974
R2550 VSS.n243 VSS.n241 0.189974
R2551 VSS.n245 VSS.n243 0.189974
R2552 VSS.n247 VSS.n245 0.189974
R2553 VSS.n249 VSS.n247 0.189974
R2554 VSS.n251 VSS.n249 0.189974
R2555 VSS.n257 VSS.n255 0.189974
R2556 VSS.n259 VSS.n257 0.189974
R2557 VSS.n261 VSS.n259 0.189974
R2558 VSS.n263 VSS.n261 0.189974
R2559 VSS.n265 VSS.n263 0.189974
R2560 VSS.n267 VSS.n265 0.189974
R2561 VSS.n273 VSS.n271 0.189974
R2562 VSS.n275 VSS.n273 0.189974
R2563 VSS.n281 VSS.n279 0.189974
R2564 VSS.n283 VSS.n281 0.189974
R2565 VSS.n289 VSS.n287 0.189974
R2566 VSS.n291 VSS.n289 0.189974
R2567 VSS.n312 VSS.n0 0.020105
R2568 VSS.n311 VSS.n310 0.0054955
R2569 VSS.n311 VSS.n1 0.0054955
R2570 a_21324_6400.n206 a_21324_6400.t127 113.632
R2571 a_21324_6400.n252 a_21324_6400.t64 113.632
R2572 a_21324_6400.n81 a_21324_6400.t191 113.632
R2573 a_21324_6400.n127 a_21324_6400.t128 113.632
R2574 a_21324_6400.n297 a_21324_6400.t95 109.174
R2575 a_21324_6400.n298 a_21324_6400.t96 109.174
R2576 a_21324_6400.n207 a_21324_6400.t126 109.174
R2577 a_21324_6400.n208 a_21324_6400.t125 109.174
R2578 a_21324_6400.n209 a_21324_6400.t124 109.174
R2579 a_21324_6400.n210 a_21324_6400.t123 109.174
R2580 a_21324_6400.n211 a_21324_6400.t122 109.174
R2581 a_21324_6400.n212 a_21324_6400.t121 109.174
R2582 a_21324_6400.n213 a_21324_6400.t120 109.174
R2583 a_21324_6400.n214 a_21324_6400.t119 109.174
R2584 a_21324_6400.n215 a_21324_6400.t118 109.174
R2585 a_21324_6400.n216 a_21324_6400.t117 109.174
R2586 a_21324_6400.n217 a_21324_6400.t116 109.174
R2587 a_21324_6400.n218 a_21324_6400.t115 109.174
R2588 a_21324_6400.n219 a_21324_6400.t114 109.174
R2589 a_21324_6400.n220 a_21324_6400.t113 109.174
R2590 a_21324_6400.n221 a_21324_6400.t112 109.174
R2591 a_21324_6400.n222 a_21324_6400.t111 109.174
R2592 a_21324_6400.n223 a_21324_6400.t110 109.174
R2593 a_21324_6400.n224 a_21324_6400.t109 109.174
R2594 a_21324_6400.n225 a_21324_6400.t108 109.174
R2595 a_21324_6400.n226 a_21324_6400.t107 109.174
R2596 a_21324_6400.n227 a_21324_6400.t106 109.174
R2597 a_21324_6400.n228 a_21324_6400.t105 109.174
R2598 a_21324_6400.n229 a_21324_6400.t104 109.174
R2599 a_21324_6400.n230 a_21324_6400.t103 109.174
R2600 a_21324_6400.n231 a_21324_6400.t102 109.174
R2601 a_21324_6400.n232 a_21324_6400.t101 109.174
R2602 a_21324_6400.n233 a_21324_6400.t100 109.174
R2603 a_21324_6400.n234 a_21324_6400.t99 109.174
R2604 a_21324_6400.n235 a_21324_6400.t98 109.174
R2605 a_21324_6400.n236 a_21324_6400.t97 109.174
R2606 a_21324_6400.n296 a_21324_6400.t94 109.174
R2607 a_21324_6400.n237 a_21324_6400.t93 109.174
R2608 a_21324_6400.n292 a_21324_6400.t92 109.174
R2609 a_21324_6400.n291 a_21324_6400.t91 109.174
R2610 a_21324_6400.n290 a_21324_6400.t90 109.174
R2611 a_21324_6400.n239 a_21324_6400.t89 109.174
R2612 a_21324_6400.n286 a_21324_6400.t88 109.174
R2613 a_21324_6400.n285 a_21324_6400.t87 109.174
R2614 a_21324_6400.n284 a_21324_6400.t86 109.174
R2615 a_21324_6400.n241 a_21324_6400.t85 109.174
R2616 a_21324_6400.n280 a_21324_6400.t84 109.174
R2617 a_21324_6400.n279 a_21324_6400.t83 109.174
R2618 a_21324_6400.n278 a_21324_6400.t82 109.174
R2619 a_21324_6400.n243 a_21324_6400.t81 109.174
R2620 a_21324_6400.n274 a_21324_6400.t80 109.174
R2621 a_21324_6400.n273 a_21324_6400.t79 109.174
R2622 a_21324_6400.n272 a_21324_6400.t78 109.174
R2623 a_21324_6400.n245 a_21324_6400.t77 109.174
R2624 a_21324_6400.n268 a_21324_6400.t76 109.174
R2625 a_21324_6400.n267 a_21324_6400.t75 109.174
R2626 a_21324_6400.n266 a_21324_6400.t74 109.174
R2627 a_21324_6400.n247 a_21324_6400.t73 109.174
R2628 a_21324_6400.n262 a_21324_6400.t72 109.174
R2629 a_21324_6400.n261 a_21324_6400.t71 109.174
R2630 a_21324_6400.n260 a_21324_6400.t70 109.174
R2631 a_21324_6400.n249 a_21324_6400.t69 109.174
R2632 a_21324_6400.n256 a_21324_6400.t68 109.174
R2633 a_21324_6400.n255 a_21324_6400.t67 109.174
R2634 a_21324_6400.n254 a_21324_6400.t66 109.174
R2635 a_21324_6400.n251 a_21324_6400.t65 109.174
R2636 a_21324_6400.n172 a_21324_6400.t159 109.174
R2637 a_21324_6400.n173 a_21324_6400.t160 109.174
R2638 a_21324_6400.n82 a_21324_6400.t190 109.174
R2639 a_21324_6400.n83 a_21324_6400.t189 109.174
R2640 a_21324_6400.n84 a_21324_6400.t188 109.174
R2641 a_21324_6400.n85 a_21324_6400.t187 109.174
R2642 a_21324_6400.n86 a_21324_6400.t186 109.174
R2643 a_21324_6400.n87 a_21324_6400.t185 109.174
R2644 a_21324_6400.n88 a_21324_6400.t184 109.174
R2645 a_21324_6400.n89 a_21324_6400.t183 109.174
R2646 a_21324_6400.n90 a_21324_6400.t182 109.174
R2647 a_21324_6400.n91 a_21324_6400.t181 109.174
R2648 a_21324_6400.n92 a_21324_6400.t180 109.174
R2649 a_21324_6400.n93 a_21324_6400.t179 109.174
R2650 a_21324_6400.n94 a_21324_6400.t178 109.174
R2651 a_21324_6400.n95 a_21324_6400.t177 109.174
R2652 a_21324_6400.n96 a_21324_6400.t176 109.174
R2653 a_21324_6400.n97 a_21324_6400.t175 109.174
R2654 a_21324_6400.n98 a_21324_6400.t174 109.174
R2655 a_21324_6400.n99 a_21324_6400.t173 109.174
R2656 a_21324_6400.n100 a_21324_6400.t172 109.174
R2657 a_21324_6400.n101 a_21324_6400.t171 109.174
R2658 a_21324_6400.n102 a_21324_6400.t170 109.174
R2659 a_21324_6400.n103 a_21324_6400.t169 109.174
R2660 a_21324_6400.n104 a_21324_6400.t168 109.174
R2661 a_21324_6400.n105 a_21324_6400.t167 109.174
R2662 a_21324_6400.n106 a_21324_6400.t166 109.174
R2663 a_21324_6400.n107 a_21324_6400.t165 109.174
R2664 a_21324_6400.n108 a_21324_6400.t164 109.174
R2665 a_21324_6400.n109 a_21324_6400.t163 109.174
R2666 a_21324_6400.n110 a_21324_6400.t162 109.174
R2667 a_21324_6400.n111 a_21324_6400.t161 109.174
R2668 a_21324_6400.n171 a_21324_6400.t158 109.174
R2669 a_21324_6400.n112 a_21324_6400.t157 109.174
R2670 a_21324_6400.n167 a_21324_6400.t156 109.174
R2671 a_21324_6400.n166 a_21324_6400.t155 109.174
R2672 a_21324_6400.n165 a_21324_6400.t154 109.174
R2673 a_21324_6400.n114 a_21324_6400.t153 109.174
R2674 a_21324_6400.n161 a_21324_6400.t152 109.174
R2675 a_21324_6400.n160 a_21324_6400.t151 109.174
R2676 a_21324_6400.n159 a_21324_6400.t150 109.174
R2677 a_21324_6400.n116 a_21324_6400.t149 109.174
R2678 a_21324_6400.n155 a_21324_6400.t148 109.174
R2679 a_21324_6400.n154 a_21324_6400.t147 109.174
R2680 a_21324_6400.n153 a_21324_6400.t146 109.174
R2681 a_21324_6400.n118 a_21324_6400.t145 109.174
R2682 a_21324_6400.n149 a_21324_6400.t144 109.174
R2683 a_21324_6400.n148 a_21324_6400.t143 109.174
R2684 a_21324_6400.n147 a_21324_6400.t142 109.174
R2685 a_21324_6400.n120 a_21324_6400.t141 109.174
R2686 a_21324_6400.n143 a_21324_6400.t140 109.174
R2687 a_21324_6400.n142 a_21324_6400.t139 109.174
R2688 a_21324_6400.n141 a_21324_6400.t138 109.174
R2689 a_21324_6400.n122 a_21324_6400.t137 109.174
R2690 a_21324_6400.n137 a_21324_6400.t136 109.174
R2691 a_21324_6400.n136 a_21324_6400.t135 109.174
R2692 a_21324_6400.n135 a_21324_6400.t134 109.174
R2693 a_21324_6400.n124 a_21324_6400.t133 109.174
R2694 a_21324_6400.n131 a_21324_6400.t132 109.174
R2695 a_21324_6400.n130 a_21324_6400.t131 109.174
R2696 a_21324_6400.n129 a_21324_6400.t130 109.174
R2697 a_21324_6400.n126 a_21324_6400.t129 109.174
R2698 a_21324_6400.n302 a_21324_6400.n301 21.3114
R2699 a_21324_6400.n297 a_21324_6400.n176 18.4942
R2700 a_21324_6400.n299 a_21324_6400.n298 18.4942
R2701 a_21324_6400.n208 a_21324_6400.n205 18.4942
R2702 a_21324_6400.n209 a_21324_6400.n204 18.4942
R2703 a_21324_6400.n210 a_21324_6400.n203 18.4942
R2704 a_21324_6400.n211 a_21324_6400.n202 18.4942
R2705 a_21324_6400.n212 a_21324_6400.n201 18.4942
R2706 a_21324_6400.n213 a_21324_6400.n200 18.4942
R2707 a_21324_6400.n214 a_21324_6400.n199 18.4942
R2708 a_21324_6400.n215 a_21324_6400.n198 18.4942
R2709 a_21324_6400.n216 a_21324_6400.n197 18.4942
R2710 a_21324_6400.n217 a_21324_6400.n196 18.4942
R2711 a_21324_6400.n218 a_21324_6400.n195 18.4942
R2712 a_21324_6400.n219 a_21324_6400.n194 18.4942
R2713 a_21324_6400.n220 a_21324_6400.n193 18.4942
R2714 a_21324_6400.n221 a_21324_6400.n192 18.4942
R2715 a_21324_6400.n222 a_21324_6400.n191 18.4942
R2716 a_21324_6400.n223 a_21324_6400.n190 18.4942
R2717 a_21324_6400.n224 a_21324_6400.n189 18.4942
R2718 a_21324_6400.n225 a_21324_6400.n188 18.4942
R2719 a_21324_6400.n226 a_21324_6400.n187 18.4942
R2720 a_21324_6400.n227 a_21324_6400.n186 18.4942
R2721 a_21324_6400.n228 a_21324_6400.n185 18.4942
R2722 a_21324_6400.n229 a_21324_6400.n184 18.4942
R2723 a_21324_6400.n230 a_21324_6400.n183 18.4942
R2724 a_21324_6400.n231 a_21324_6400.n182 18.4942
R2725 a_21324_6400.n232 a_21324_6400.n181 18.4942
R2726 a_21324_6400.n233 a_21324_6400.n180 18.4942
R2727 a_21324_6400.n234 a_21324_6400.n179 18.4942
R2728 a_21324_6400.n235 a_21324_6400.n178 18.4942
R2729 a_21324_6400.n236 a_21324_6400.n177 18.4942
R2730 a_21324_6400.n296 a_21324_6400.n295 18.4942
R2731 a_21324_6400.n294 a_21324_6400.n237 18.4942
R2732 a_21324_6400.n293 a_21324_6400.n292 18.4942
R2733 a_21324_6400.n291 a_21324_6400.n238 18.4942
R2734 a_21324_6400.n290 a_21324_6400.n289 18.4942
R2735 a_21324_6400.n288 a_21324_6400.n239 18.4942
R2736 a_21324_6400.n287 a_21324_6400.n286 18.4942
R2737 a_21324_6400.n285 a_21324_6400.n240 18.4942
R2738 a_21324_6400.n284 a_21324_6400.n283 18.4942
R2739 a_21324_6400.n282 a_21324_6400.n241 18.4942
R2740 a_21324_6400.n281 a_21324_6400.n280 18.4942
R2741 a_21324_6400.n279 a_21324_6400.n242 18.4942
R2742 a_21324_6400.n278 a_21324_6400.n277 18.4942
R2743 a_21324_6400.n276 a_21324_6400.n243 18.4942
R2744 a_21324_6400.n275 a_21324_6400.n274 18.4942
R2745 a_21324_6400.n273 a_21324_6400.n244 18.4942
R2746 a_21324_6400.n272 a_21324_6400.n271 18.4942
R2747 a_21324_6400.n270 a_21324_6400.n245 18.4942
R2748 a_21324_6400.n269 a_21324_6400.n268 18.4942
R2749 a_21324_6400.n267 a_21324_6400.n246 18.4942
R2750 a_21324_6400.n266 a_21324_6400.n265 18.4942
R2751 a_21324_6400.n264 a_21324_6400.n247 18.4942
R2752 a_21324_6400.n263 a_21324_6400.n262 18.4942
R2753 a_21324_6400.n261 a_21324_6400.n248 18.4942
R2754 a_21324_6400.n260 a_21324_6400.n259 18.4942
R2755 a_21324_6400.n258 a_21324_6400.n249 18.4942
R2756 a_21324_6400.n257 a_21324_6400.n256 18.4942
R2757 a_21324_6400.n255 a_21324_6400.n250 18.4942
R2758 a_21324_6400.n254 a_21324_6400.n253 18.4942
R2759 a_21324_6400.n172 a_21324_6400.n51 18.4942
R2760 a_21324_6400.n174 a_21324_6400.n173 18.4942
R2761 a_21324_6400.n83 a_21324_6400.n80 18.4942
R2762 a_21324_6400.n84 a_21324_6400.n79 18.4942
R2763 a_21324_6400.n85 a_21324_6400.n78 18.4942
R2764 a_21324_6400.n86 a_21324_6400.n77 18.4942
R2765 a_21324_6400.n87 a_21324_6400.n76 18.4942
R2766 a_21324_6400.n88 a_21324_6400.n75 18.4942
R2767 a_21324_6400.n89 a_21324_6400.n74 18.4942
R2768 a_21324_6400.n90 a_21324_6400.n73 18.4942
R2769 a_21324_6400.n91 a_21324_6400.n72 18.4942
R2770 a_21324_6400.n92 a_21324_6400.n71 18.4942
R2771 a_21324_6400.n93 a_21324_6400.n70 18.4942
R2772 a_21324_6400.n94 a_21324_6400.n69 18.4942
R2773 a_21324_6400.n95 a_21324_6400.n68 18.4942
R2774 a_21324_6400.n96 a_21324_6400.n67 18.4942
R2775 a_21324_6400.n97 a_21324_6400.n66 18.4942
R2776 a_21324_6400.n98 a_21324_6400.n65 18.4942
R2777 a_21324_6400.n99 a_21324_6400.n64 18.4942
R2778 a_21324_6400.n100 a_21324_6400.n63 18.4942
R2779 a_21324_6400.n101 a_21324_6400.n62 18.4942
R2780 a_21324_6400.n102 a_21324_6400.n61 18.4942
R2781 a_21324_6400.n103 a_21324_6400.n60 18.4942
R2782 a_21324_6400.n104 a_21324_6400.n59 18.4942
R2783 a_21324_6400.n105 a_21324_6400.n58 18.4942
R2784 a_21324_6400.n106 a_21324_6400.n57 18.4942
R2785 a_21324_6400.n107 a_21324_6400.n56 18.4942
R2786 a_21324_6400.n108 a_21324_6400.n55 18.4942
R2787 a_21324_6400.n109 a_21324_6400.n54 18.4942
R2788 a_21324_6400.n110 a_21324_6400.n53 18.4942
R2789 a_21324_6400.n111 a_21324_6400.n52 18.4942
R2790 a_21324_6400.n171 a_21324_6400.n170 18.4942
R2791 a_21324_6400.n169 a_21324_6400.n112 18.4942
R2792 a_21324_6400.n168 a_21324_6400.n167 18.4942
R2793 a_21324_6400.n166 a_21324_6400.n113 18.4942
R2794 a_21324_6400.n165 a_21324_6400.n164 18.4942
R2795 a_21324_6400.n163 a_21324_6400.n114 18.4942
R2796 a_21324_6400.n162 a_21324_6400.n161 18.4942
R2797 a_21324_6400.n160 a_21324_6400.n115 18.4942
R2798 a_21324_6400.n159 a_21324_6400.n158 18.4942
R2799 a_21324_6400.n157 a_21324_6400.n116 18.4942
R2800 a_21324_6400.n156 a_21324_6400.n155 18.4942
R2801 a_21324_6400.n154 a_21324_6400.n117 18.4942
R2802 a_21324_6400.n153 a_21324_6400.n152 18.4942
R2803 a_21324_6400.n151 a_21324_6400.n118 18.4942
R2804 a_21324_6400.n150 a_21324_6400.n149 18.4942
R2805 a_21324_6400.n148 a_21324_6400.n119 18.4942
R2806 a_21324_6400.n147 a_21324_6400.n146 18.4942
R2807 a_21324_6400.n145 a_21324_6400.n120 18.4942
R2808 a_21324_6400.n144 a_21324_6400.n143 18.4942
R2809 a_21324_6400.n142 a_21324_6400.n121 18.4942
R2810 a_21324_6400.n141 a_21324_6400.n140 18.4942
R2811 a_21324_6400.n139 a_21324_6400.n122 18.4942
R2812 a_21324_6400.n138 a_21324_6400.n137 18.4942
R2813 a_21324_6400.n136 a_21324_6400.n123 18.4942
R2814 a_21324_6400.n135 a_21324_6400.n134 18.4942
R2815 a_21324_6400.n133 a_21324_6400.n124 18.4942
R2816 a_21324_6400.n132 a_21324_6400.n131 18.4942
R2817 a_21324_6400.n130 a_21324_6400.n125 18.4942
R2818 a_21324_6400.n129 a_21324_6400.n128 18.4942
R2819 a_21324_6400.n297 a_21324_6400.n296 11.6805
R2820 a_21324_6400.n298 a_21324_6400.n297 11.6805
R2821 a_21324_6400.n208 a_21324_6400.n207 11.6805
R2822 a_21324_6400.n209 a_21324_6400.n208 11.6805
R2823 a_21324_6400.n210 a_21324_6400.n209 11.6805
R2824 a_21324_6400.n211 a_21324_6400.n210 11.6805
R2825 a_21324_6400.n212 a_21324_6400.n211 11.6805
R2826 a_21324_6400.n213 a_21324_6400.n212 11.6805
R2827 a_21324_6400.n214 a_21324_6400.n213 11.6805
R2828 a_21324_6400.n215 a_21324_6400.n214 11.6805
R2829 a_21324_6400.n216 a_21324_6400.n215 11.6805
R2830 a_21324_6400.n217 a_21324_6400.n216 11.6805
R2831 a_21324_6400.n218 a_21324_6400.n217 11.6805
R2832 a_21324_6400.n219 a_21324_6400.n218 11.6805
R2833 a_21324_6400.n220 a_21324_6400.n219 11.6805
R2834 a_21324_6400.n221 a_21324_6400.n220 11.6805
R2835 a_21324_6400.n222 a_21324_6400.n221 11.6805
R2836 a_21324_6400.n223 a_21324_6400.n222 11.6805
R2837 a_21324_6400.n224 a_21324_6400.n223 11.6805
R2838 a_21324_6400.n225 a_21324_6400.n224 11.6805
R2839 a_21324_6400.n226 a_21324_6400.n225 11.6805
R2840 a_21324_6400.n227 a_21324_6400.n226 11.6805
R2841 a_21324_6400.n228 a_21324_6400.n227 11.6805
R2842 a_21324_6400.n229 a_21324_6400.n228 11.6805
R2843 a_21324_6400.n230 a_21324_6400.n229 11.6805
R2844 a_21324_6400.n231 a_21324_6400.n230 11.6805
R2845 a_21324_6400.n232 a_21324_6400.n231 11.6805
R2846 a_21324_6400.n233 a_21324_6400.n232 11.6805
R2847 a_21324_6400.n234 a_21324_6400.n233 11.6805
R2848 a_21324_6400.n235 a_21324_6400.n234 11.6805
R2849 a_21324_6400.n236 a_21324_6400.n235 11.6805
R2850 a_21324_6400.n298 a_21324_6400.n236 11.6805
R2851 a_21324_6400.n296 a_21324_6400.n237 11.6805
R2852 a_21324_6400.n292 a_21324_6400.n237 11.6805
R2853 a_21324_6400.n292 a_21324_6400.n291 11.6805
R2854 a_21324_6400.n291 a_21324_6400.n290 11.6805
R2855 a_21324_6400.n290 a_21324_6400.n239 11.6805
R2856 a_21324_6400.n286 a_21324_6400.n239 11.6805
R2857 a_21324_6400.n286 a_21324_6400.n285 11.6805
R2858 a_21324_6400.n285 a_21324_6400.n284 11.6805
R2859 a_21324_6400.n284 a_21324_6400.n241 11.6805
R2860 a_21324_6400.n280 a_21324_6400.n241 11.6805
R2861 a_21324_6400.n280 a_21324_6400.n279 11.6805
R2862 a_21324_6400.n279 a_21324_6400.n278 11.6805
R2863 a_21324_6400.n278 a_21324_6400.n243 11.6805
R2864 a_21324_6400.n274 a_21324_6400.n243 11.6805
R2865 a_21324_6400.n274 a_21324_6400.n273 11.6805
R2866 a_21324_6400.n273 a_21324_6400.n272 11.6805
R2867 a_21324_6400.n272 a_21324_6400.n245 11.6805
R2868 a_21324_6400.n268 a_21324_6400.n245 11.6805
R2869 a_21324_6400.n268 a_21324_6400.n267 11.6805
R2870 a_21324_6400.n267 a_21324_6400.n266 11.6805
R2871 a_21324_6400.n266 a_21324_6400.n247 11.6805
R2872 a_21324_6400.n262 a_21324_6400.n247 11.6805
R2873 a_21324_6400.n262 a_21324_6400.n261 11.6805
R2874 a_21324_6400.n261 a_21324_6400.n260 11.6805
R2875 a_21324_6400.n260 a_21324_6400.n249 11.6805
R2876 a_21324_6400.n256 a_21324_6400.n249 11.6805
R2877 a_21324_6400.n256 a_21324_6400.n255 11.6805
R2878 a_21324_6400.n255 a_21324_6400.n254 11.6805
R2879 a_21324_6400.n254 a_21324_6400.n251 11.6805
R2880 a_21324_6400.n172 a_21324_6400.n171 11.6805
R2881 a_21324_6400.n173 a_21324_6400.n172 11.6805
R2882 a_21324_6400.n83 a_21324_6400.n82 11.6805
R2883 a_21324_6400.n84 a_21324_6400.n83 11.6805
R2884 a_21324_6400.n85 a_21324_6400.n84 11.6805
R2885 a_21324_6400.n86 a_21324_6400.n85 11.6805
R2886 a_21324_6400.n87 a_21324_6400.n86 11.6805
R2887 a_21324_6400.n88 a_21324_6400.n87 11.6805
R2888 a_21324_6400.n89 a_21324_6400.n88 11.6805
R2889 a_21324_6400.n90 a_21324_6400.n89 11.6805
R2890 a_21324_6400.n91 a_21324_6400.n90 11.6805
R2891 a_21324_6400.n92 a_21324_6400.n91 11.6805
R2892 a_21324_6400.n93 a_21324_6400.n92 11.6805
R2893 a_21324_6400.n94 a_21324_6400.n93 11.6805
R2894 a_21324_6400.n95 a_21324_6400.n94 11.6805
R2895 a_21324_6400.n96 a_21324_6400.n95 11.6805
R2896 a_21324_6400.n97 a_21324_6400.n96 11.6805
R2897 a_21324_6400.n98 a_21324_6400.n97 11.6805
R2898 a_21324_6400.n99 a_21324_6400.n98 11.6805
R2899 a_21324_6400.n100 a_21324_6400.n99 11.6805
R2900 a_21324_6400.n101 a_21324_6400.n100 11.6805
R2901 a_21324_6400.n102 a_21324_6400.n101 11.6805
R2902 a_21324_6400.n103 a_21324_6400.n102 11.6805
R2903 a_21324_6400.n104 a_21324_6400.n103 11.6805
R2904 a_21324_6400.n105 a_21324_6400.n104 11.6805
R2905 a_21324_6400.n106 a_21324_6400.n105 11.6805
R2906 a_21324_6400.n107 a_21324_6400.n106 11.6805
R2907 a_21324_6400.n108 a_21324_6400.n107 11.6805
R2908 a_21324_6400.n109 a_21324_6400.n108 11.6805
R2909 a_21324_6400.n110 a_21324_6400.n109 11.6805
R2910 a_21324_6400.n111 a_21324_6400.n110 11.6805
R2911 a_21324_6400.n173 a_21324_6400.n111 11.6805
R2912 a_21324_6400.n171 a_21324_6400.n112 11.6805
R2913 a_21324_6400.n167 a_21324_6400.n112 11.6805
R2914 a_21324_6400.n167 a_21324_6400.n166 11.6805
R2915 a_21324_6400.n166 a_21324_6400.n165 11.6805
R2916 a_21324_6400.n165 a_21324_6400.n114 11.6805
R2917 a_21324_6400.n161 a_21324_6400.n114 11.6805
R2918 a_21324_6400.n161 a_21324_6400.n160 11.6805
R2919 a_21324_6400.n160 a_21324_6400.n159 11.6805
R2920 a_21324_6400.n159 a_21324_6400.n116 11.6805
R2921 a_21324_6400.n155 a_21324_6400.n116 11.6805
R2922 a_21324_6400.n155 a_21324_6400.n154 11.6805
R2923 a_21324_6400.n154 a_21324_6400.n153 11.6805
R2924 a_21324_6400.n153 a_21324_6400.n118 11.6805
R2925 a_21324_6400.n149 a_21324_6400.n118 11.6805
R2926 a_21324_6400.n149 a_21324_6400.n148 11.6805
R2927 a_21324_6400.n148 a_21324_6400.n147 11.6805
R2928 a_21324_6400.n147 a_21324_6400.n120 11.6805
R2929 a_21324_6400.n143 a_21324_6400.n120 11.6805
R2930 a_21324_6400.n143 a_21324_6400.n142 11.6805
R2931 a_21324_6400.n142 a_21324_6400.n141 11.6805
R2932 a_21324_6400.n141 a_21324_6400.n122 11.6805
R2933 a_21324_6400.n137 a_21324_6400.n122 11.6805
R2934 a_21324_6400.n137 a_21324_6400.n136 11.6805
R2935 a_21324_6400.n136 a_21324_6400.n135 11.6805
R2936 a_21324_6400.n135 a_21324_6400.n124 11.6805
R2937 a_21324_6400.n131 a_21324_6400.n124 11.6805
R2938 a_21324_6400.n131 a_21324_6400.n130 11.6805
R2939 a_21324_6400.n130 a_21324_6400.n129 11.6805
R2940 a_21324_6400.n129 a_21324_6400.n126 11.6805
R2941 a_21324_6400.n301 a_21324_6400.n175 10.3505
R2942 a_21324_6400.n301 a_21324_6400.n300 9.57907
R2943 a_21324_6400.n253 a_21324_6400.n252 7.17687
R2944 a_21324_6400.n206 a_21324_6400.n205 7.17687
R2945 a_21324_6400.n128 a_21324_6400.n127 7.17687
R2946 a_21324_6400.n81 a_21324_6400.n80 7.17687
R2947 a_21324_6400.n302 a_21324_6400.n50 6.5392
R2948 a_21324_6400.n1 a_21324_6400.t52 5.7796
R2949 a_21324_6400.n21 a_21324_6400.t62 5.73764
R2950 a_21324_6400.n303 a_21324_6400.t61 5.59012
R2951 a_21324_6400.n50 a_21324_6400.t31 5.54817
R2952 a_21324_6400.n313 a_21324_6400.n312 5.38537
R2953 a_21324_6400.n1 a_21324_6400.n0 5.38537
R2954 a_21324_6400.n3 a_21324_6400.n2 5.38537
R2955 a_21324_6400.n5 a_21324_6400.n4 5.38537
R2956 a_21324_6400.n7 a_21324_6400.n6 5.38537
R2957 a_21324_6400.n9 a_21324_6400.n8 5.38537
R2958 a_21324_6400.n11 a_21324_6400.n10 5.38537
R2959 a_21324_6400.n13 a_21324_6400.n12 5.38537
R2960 a_21324_6400.n15 a_21324_6400.n14 5.38537
R2961 a_21324_6400.n17 a_21324_6400.n16 5.38537
R2962 a_21324_6400.n19 a_21324_6400.n18 5.38537
R2963 a_21324_6400.n311 a_21324_6400.n310 5.38537
R2964 a_21324_6400.n309 a_21324_6400.n308 5.38537
R2965 a_21324_6400.n307 a_21324_6400.n306 5.38537
R2966 a_21324_6400.n305 a_21324_6400.n304 5.38537
R2967 a_21324_6400.n21 a_21324_6400.n20 5.32067
R2968 a_21324_6400.n23 a_21324_6400.n22 5.32067
R2969 a_21324_6400.n25 a_21324_6400.n24 5.32067
R2970 a_21324_6400.n27 a_21324_6400.n26 5.32067
R2971 a_21324_6400.n29 a_21324_6400.n28 5.32067
R2972 a_21324_6400.n31 a_21324_6400.n30 5.32067
R2973 a_21324_6400.n33 a_21324_6400.n32 5.32067
R2974 a_21324_6400.n35 a_21324_6400.n34 5.32067
R2975 a_21324_6400.n37 a_21324_6400.n36 5.32067
R2976 a_21324_6400.n39 a_21324_6400.n38 5.32067
R2977 a_21324_6400.n41 a_21324_6400.n40 5.32067
R2978 a_21324_6400.n43 a_21324_6400.n42 5.32067
R2979 a_21324_6400.n45 a_21324_6400.n44 5.32067
R2980 a_21324_6400.n47 a_21324_6400.n46 5.32067
R2981 a_21324_6400.n49 a_21324_6400.n48 5.32067
R2982 a_21324_6400.n303 a_21324_6400.n302 4.61063
R2983 a_21324_6400.n207 a_21324_6400.n206 4.42851
R2984 a_21324_6400.n252 a_21324_6400.n251 4.42851
R2985 a_21324_6400.n82 a_21324_6400.n81 4.42851
R2986 a_21324_6400.n127 a_21324_6400.n126 4.42851
R2987 a_21324_6400.n20 a_21324_6400.t25 0.228
R2988 a_21324_6400.n20 a_21324_6400.t63 0.228
R2989 a_21324_6400.n22 a_21324_6400.t27 0.228
R2990 a_21324_6400.n22 a_21324_6400.t26 0.228
R2991 a_21324_6400.n24 a_21324_6400.t23 0.228
R2992 a_21324_6400.n24 a_21324_6400.t22 0.228
R2993 a_21324_6400.n26 a_21324_6400.t19 0.228
R2994 a_21324_6400.n26 a_21324_6400.t24 0.228
R2995 a_21324_6400.n28 a_21324_6400.t21 0.228
R2996 a_21324_6400.n28 a_21324_6400.t20 0.228
R2997 a_21324_6400.n30 a_21324_6400.t39 0.228
R2998 a_21324_6400.n30 a_21324_6400.t38 0.228
R2999 a_21324_6400.n32 a_21324_6400.t37 0.228
R3000 a_21324_6400.n32 a_21324_6400.t36 0.228
R3001 a_21324_6400.n34 a_21324_6400.t18 0.228
R3002 a_21324_6400.n34 a_21324_6400.t17 0.228
R3003 a_21324_6400.n36 a_21324_6400.t14 0.228
R3004 a_21324_6400.n36 a_21324_6400.t13 0.228
R3005 a_21324_6400.n38 a_21324_6400.t16 0.228
R3006 a_21324_6400.n38 a_21324_6400.t15 0.228
R3007 a_21324_6400.n40 a_21324_6400.t12 0.228
R3008 a_21324_6400.n40 a_21324_6400.t11 0.228
R3009 a_21324_6400.n42 a_21324_6400.t55 0.228
R3010 a_21324_6400.n42 a_21324_6400.t54 0.228
R3011 a_21324_6400.n44 a_21324_6400.t60 0.228
R3012 a_21324_6400.n44 a_21324_6400.t59 0.228
R3013 a_21324_6400.n46 a_21324_6400.t35 0.228
R3014 a_21324_6400.n46 a_21324_6400.t34 0.228
R3015 a_21324_6400.n48 a_21324_6400.t33 0.228
R3016 a_21324_6400.n48 a_21324_6400.t32 0.228
R3017 a_21324_6400.t0 a_21324_6400.n313 0.20525
R3018 a_21324_6400.n313 a_21324_6400.t6 0.20525
R3019 a_21324_6400.n0 a_21324_6400.t44 0.20525
R3020 a_21324_6400.n0 a_21324_6400.t53 0.20525
R3021 a_21324_6400.n2 a_21324_6400.t46 0.20525
R3022 a_21324_6400.n2 a_21324_6400.t45 0.20525
R3023 a_21324_6400.n4 a_21324_6400.t40 0.20525
R3024 a_21324_6400.n4 a_21324_6400.t47 0.20525
R3025 a_21324_6400.n6 a_21324_6400.t42 0.20525
R3026 a_21324_6400.n6 a_21324_6400.t41 0.20525
R3027 a_21324_6400.n8 a_21324_6400.t48 0.20525
R3028 a_21324_6400.n8 a_21324_6400.t43 0.20525
R3029 a_21324_6400.n10 a_21324_6400.t50 0.20525
R3030 a_21324_6400.n10 a_21324_6400.t49 0.20525
R3031 a_21324_6400.n12 a_21324_6400.t7 0.20525
R3032 a_21324_6400.n12 a_21324_6400.t51 0.20525
R3033 a_21324_6400.n14 a_21324_6400.t9 0.20525
R3034 a_21324_6400.n14 a_21324_6400.t8 0.20525
R3035 a_21324_6400.n16 a_21324_6400.t3 0.20525
R3036 a_21324_6400.n16 a_21324_6400.t10 0.20525
R3037 a_21324_6400.n18 a_21324_6400.t5 0.20525
R3038 a_21324_6400.n18 a_21324_6400.t4 0.20525
R3039 a_21324_6400.n310 a_21324_6400.t2 0.20525
R3040 a_21324_6400.n310 a_21324_6400.t1 0.20525
R3041 a_21324_6400.n308 a_21324_6400.t29 0.20525
R3042 a_21324_6400.n308 a_21324_6400.t28 0.20525
R3043 a_21324_6400.n306 a_21324_6400.t56 0.20525
R3044 a_21324_6400.n306 a_21324_6400.t30 0.20525
R3045 a_21324_6400.n304 a_21324_6400.t58 0.20525
R3046 a_21324_6400.n304 a_21324_6400.t57 0.20525
R3047 a_21324_6400.n305 a_21324_6400.n303 0.189974
R3048 a_21324_6400.n307 a_21324_6400.n305 0.189974
R3049 a_21324_6400.n309 a_21324_6400.n307 0.189974
R3050 a_21324_6400.n311 a_21324_6400.n309 0.189974
R3051 a_21324_6400.n312 a_21324_6400.n311 0.189974
R3052 a_21324_6400.n312 a_21324_6400.n19 0.189974
R3053 a_21324_6400.n19 a_21324_6400.n17 0.189974
R3054 a_21324_6400.n17 a_21324_6400.n15 0.189974
R3055 a_21324_6400.n15 a_21324_6400.n13 0.189974
R3056 a_21324_6400.n13 a_21324_6400.n11 0.189974
R3057 a_21324_6400.n11 a_21324_6400.n9 0.189974
R3058 a_21324_6400.n9 a_21324_6400.n7 0.189974
R3059 a_21324_6400.n7 a_21324_6400.n5 0.189974
R3060 a_21324_6400.n5 a_21324_6400.n3 0.189974
R3061 a_21324_6400.n3 a_21324_6400.n1 0.189974
R3062 a_21324_6400.n50 a_21324_6400.n49 0.189974
R3063 a_21324_6400.n49 a_21324_6400.n47 0.189974
R3064 a_21324_6400.n47 a_21324_6400.n45 0.189974
R3065 a_21324_6400.n45 a_21324_6400.n43 0.189974
R3066 a_21324_6400.n43 a_21324_6400.n41 0.189974
R3067 a_21324_6400.n41 a_21324_6400.n39 0.189974
R3068 a_21324_6400.n39 a_21324_6400.n37 0.189974
R3069 a_21324_6400.n37 a_21324_6400.n35 0.189974
R3070 a_21324_6400.n35 a_21324_6400.n33 0.189974
R3071 a_21324_6400.n33 a_21324_6400.n31 0.189974
R3072 a_21324_6400.n31 a_21324_6400.n29 0.189974
R3073 a_21324_6400.n29 a_21324_6400.n27 0.189974
R3074 a_21324_6400.n27 a_21324_6400.n25 0.189974
R3075 a_21324_6400.n25 a_21324_6400.n23 0.189974
R3076 a_21324_6400.n23 a_21324_6400.n21 0.189974
R3077 a_21324_6400.n295 a_21324_6400.n176 0.1205
R3078 a_21324_6400.n295 a_21324_6400.n294 0.1205
R3079 a_21324_6400.n294 a_21324_6400.n293 0.1205
R3080 a_21324_6400.n293 a_21324_6400.n238 0.1205
R3081 a_21324_6400.n289 a_21324_6400.n238 0.1205
R3082 a_21324_6400.n289 a_21324_6400.n288 0.1205
R3083 a_21324_6400.n288 a_21324_6400.n287 0.1205
R3084 a_21324_6400.n287 a_21324_6400.n240 0.1205
R3085 a_21324_6400.n283 a_21324_6400.n240 0.1205
R3086 a_21324_6400.n283 a_21324_6400.n282 0.1205
R3087 a_21324_6400.n282 a_21324_6400.n281 0.1205
R3088 a_21324_6400.n281 a_21324_6400.n242 0.1205
R3089 a_21324_6400.n277 a_21324_6400.n242 0.1205
R3090 a_21324_6400.n277 a_21324_6400.n276 0.1205
R3091 a_21324_6400.n276 a_21324_6400.n275 0.1205
R3092 a_21324_6400.n275 a_21324_6400.n244 0.1205
R3093 a_21324_6400.n271 a_21324_6400.n244 0.1205
R3094 a_21324_6400.n271 a_21324_6400.n270 0.1205
R3095 a_21324_6400.n270 a_21324_6400.n269 0.1205
R3096 a_21324_6400.n269 a_21324_6400.n246 0.1205
R3097 a_21324_6400.n265 a_21324_6400.n246 0.1205
R3098 a_21324_6400.n265 a_21324_6400.n264 0.1205
R3099 a_21324_6400.n264 a_21324_6400.n263 0.1205
R3100 a_21324_6400.n263 a_21324_6400.n248 0.1205
R3101 a_21324_6400.n259 a_21324_6400.n248 0.1205
R3102 a_21324_6400.n259 a_21324_6400.n258 0.1205
R3103 a_21324_6400.n258 a_21324_6400.n257 0.1205
R3104 a_21324_6400.n257 a_21324_6400.n250 0.1205
R3105 a_21324_6400.n253 a_21324_6400.n250 0.1205
R3106 a_21324_6400.n205 a_21324_6400.n204 0.1205
R3107 a_21324_6400.n204 a_21324_6400.n203 0.1205
R3108 a_21324_6400.n203 a_21324_6400.n202 0.1205
R3109 a_21324_6400.n202 a_21324_6400.n201 0.1205
R3110 a_21324_6400.n201 a_21324_6400.n200 0.1205
R3111 a_21324_6400.n200 a_21324_6400.n199 0.1205
R3112 a_21324_6400.n199 a_21324_6400.n198 0.1205
R3113 a_21324_6400.n198 a_21324_6400.n197 0.1205
R3114 a_21324_6400.n197 a_21324_6400.n196 0.1205
R3115 a_21324_6400.n196 a_21324_6400.n195 0.1205
R3116 a_21324_6400.n195 a_21324_6400.n194 0.1205
R3117 a_21324_6400.n194 a_21324_6400.n193 0.1205
R3118 a_21324_6400.n193 a_21324_6400.n192 0.1205
R3119 a_21324_6400.n192 a_21324_6400.n191 0.1205
R3120 a_21324_6400.n191 a_21324_6400.n190 0.1205
R3121 a_21324_6400.n190 a_21324_6400.n189 0.1205
R3122 a_21324_6400.n189 a_21324_6400.n188 0.1205
R3123 a_21324_6400.n188 a_21324_6400.n187 0.1205
R3124 a_21324_6400.n187 a_21324_6400.n186 0.1205
R3125 a_21324_6400.n186 a_21324_6400.n185 0.1205
R3126 a_21324_6400.n185 a_21324_6400.n184 0.1205
R3127 a_21324_6400.n184 a_21324_6400.n183 0.1205
R3128 a_21324_6400.n183 a_21324_6400.n182 0.1205
R3129 a_21324_6400.n182 a_21324_6400.n181 0.1205
R3130 a_21324_6400.n181 a_21324_6400.n180 0.1205
R3131 a_21324_6400.n180 a_21324_6400.n179 0.1205
R3132 a_21324_6400.n179 a_21324_6400.n178 0.1205
R3133 a_21324_6400.n178 a_21324_6400.n177 0.1205
R3134 a_21324_6400.n299 a_21324_6400.n177 0.1205
R3135 a_21324_6400.n170 a_21324_6400.n51 0.1205
R3136 a_21324_6400.n170 a_21324_6400.n169 0.1205
R3137 a_21324_6400.n169 a_21324_6400.n168 0.1205
R3138 a_21324_6400.n168 a_21324_6400.n113 0.1205
R3139 a_21324_6400.n164 a_21324_6400.n113 0.1205
R3140 a_21324_6400.n164 a_21324_6400.n163 0.1205
R3141 a_21324_6400.n163 a_21324_6400.n162 0.1205
R3142 a_21324_6400.n162 a_21324_6400.n115 0.1205
R3143 a_21324_6400.n158 a_21324_6400.n115 0.1205
R3144 a_21324_6400.n158 a_21324_6400.n157 0.1205
R3145 a_21324_6400.n157 a_21324_6400.n156 0.1205
R3146 a_21324_6400.n156 a_21324_6400.n117 0.1205
R3147 a_21324_6400.n152 a_21324_6400.n117 0.1205
R3148 a_21324_6400.n152 a_21324_6400.n151 0.1205
R3149 a_21324_6400.n151 a_21324_6400.n150 0.1205
R3150 a_21324_6400.n150 a_21324_6400.n119 0.1205
R3151 a_21324_6400.n146 a_21324_6400.n119 0.1205
R3152 a_21324_6400.n146 a_21324_6400.n145 0.1205
R3153 a_21324_6400.n145 a_21324_6400.n144 0.1205
R3154 a_21324_6400.n144 a_21324_6400.n121 0.1205
R3155 a_21324_6400.n140 a_21324_6400.n121 0.1205
R3156 a_21324_6400.n140 a_21324_6400.n139 0.1205
R3157 a_21324_6400.n139 a_21324_6400.n138 0.1205
R3158 a_21324_6400.n138 a_21324_6400.n123 0.1205
R3159 a_21324_6400.n134 a_21324_6400.n123 0.1205
R3160 a_21324_6400.n134 a_21324_6400.n133 0.1205
R3161 a_21324_6400.n133 a_21324_6400.n132 0.1205
R3162 a_21324_6400.n132 a_21324_6400.n125 0.1205
R3163 a_21324_6400.n128 a_21324_6400.n125 0.1205
R3164 a_21324_6400.n80 a_21324_6400.n79 0.1205
R3165 a_21324_6400.n79 a_21324_6400.n78 0.1205
R3166 a_21324_6400.n78 a_21324_6400.n77 0.1205
R3167 a_21324_6400.n77 a_21324_6400.n76 0.1205
R3168 a_21324_6400.n76 a_21324_6400.n75 0.1205
R3169 a_21324_6400.n75 a_21324_6400.n74 0.1205
R3170 a_21324_6400.n74 a_21324_6400.n73 0.1205
R3171 a_21324_6400.n73 a_21324_6400.n72 0.1205
R3172 a_21324_6400.n72 a_21324_6400.n71 0.1205
R3173 a_21324_6400.n71 a_21324_6400.n70 0.1205
R3174 a_21324_6400.n70 a_21324_6400.n69 0.1205
R3175 a_21324_6400.n69 a_21324_6400.n68 0.1205
R3176 a_21324_6400.n68 a_21324_6400.n67 0.1205
R3177 a_21324_6400.n67 a_21324_6400.n66 0.1205
R3178 a_21324_6400.n66 a_21324_6400.n65 0.1205
R3179 a_21324_6400.n65 a_21324_6400.n64 0.1205
R3180 a_21324_6400.n64 a_21324_6400.n63 0.1205
R3181 a_21324_6400.n63 a_21324_6400.n62 0.1205
R3182 a_21324_6400.n62 a_21324_6400.n61 0.1205
R3183 a_21324_6400.n61 a_21324_6400.n60 0.1205
R3184 a_21324_6400.n60 a_21324_6400.n59 0.1205
R3185 a_21324_6400.n59 a_21324_6400.n58 0.1205
R3186 a_21324_6400.n58 a_21324_6400.n57 0.1205
R3187 a_21324_6400.n57 a_21324_6400.n56 0.1205
R3188 a_21324_6400.n56 a_21324_6400.n55 0.1205
R3189 a_21324_6400.n55 a_21324_6400.n54 0.1205
R3190 a_21324_6400.n54 a_21324_6400.n53 0.1205
R3191 a_21324_6400.n53 a_21324_6400.n52 0.1205
R3192 a_21324_6400.n174 a_21324_6400.n52 0.1205
R3193 a_21324_6400.n300 a_21324_6400.n176 0.0485
R3194 a_21324_6400.n300 a_21324_6400.n299 0.0485
R3195 a_21324_6400.n175 a_21324_6400.n51 0.0485
R3196 a_21324_6400.n175 a_21324_6400.n174 0.0485
R3197 a_17292_6400.n98 a_17292_6400.t63 113.632
R3198 a_17292_6400.n120 a_17292_6400.t32 113.632
R3199 a_17292_6400.n37 a_17292_6400.t95 113.632
R3200 a_17292_6400.n59 a_17292_6400.t64 113.632
R3201 a_17292_6400.n141 a_17292_6400.t47 109.174
R3202 a_17292_6400.n142 a_17292_6400.t48 109.174
R3203 a_17292_6400.n99 a_17292_6400.t62 109.174
R3204 a_17292_6400.n100 a_17292_6400.t61 109.174
R3205 a_17292_6400.n101 a_17292_6400.t60 109.174
R3206 a_17292_6400.n102 a_17292_6400.t59 109.174
R3207 a_17292_6400.n103 a_17292_6400.t58 109.174
R3208 a_17292_6400.n104 a_17292_6400.t57 109.174
R3209 a_17292_6400.n105 a_17292_6400.t56 109.174
R3210 a_17292_6400.n106 a_17292_6400.t55 109.174
R3211 a_17292_6400.n107 a_17292_6400.t54 109.174
R3212 a_17292_6400.n108 a_17292_6400.t53 109.174
R3213 a_17292_6400.n109 a_17292_6400.t52 109.174
R3214 a_17292_6400.n110 a_17292_6400.t51 109.174
R3215 a_17292_6400.n111 a_17292_6400.t50 109.174
R3216 a_17292_6400.n112 a_17292_6400.t49 109.174
R3217 a_17292_6400.n140 a_17292_6400.t46 109.174
R3218 a_17292_6400.n113 a_17292_6400.t45 109.174
R3219 a_17292_6400.n136 a_17292_6400.t44 109.174
R3220 a_17292_6400.n135 a_17292_6400.t43 109.174
R3221 a_17292_6400.n134 a_17292_6400.t42 109.174
R3222 a_17292_6400.n115 a_17292_6400.t41 109.174
R3223 a_17292_6400.n130 a_17292_6400.t40 109.174
R3224 a_17292_6400.n129 a_17292_6400.t39 109.174
R3225 a_17292_6400.n128 a_17292_6400.t38 109.174
R3226 a_17292_6400.n117 a_17292_6400.t37 109.174
R3227 a_17292_6400.n124 a_17292_6400.t36 109.174
R3228 a_17292_6400.n123 a_17292_6400.t35 109.174
R3229 a_17292_6400.n122 a_17292_6400.t34 109.174
R3230 a_17292_6400.n119 a_17292_6400.t33 109.174
R3231 a_17292_6400.n80 a_17292_6400.t79 109.174
R3232 a_17292_6400.n81 a_17292_6400.t80 109.174
R3233 a_17292_6400.n38 a_17292_6400.t94 109.174
R3234 a_17292_6400.n39 a_17292_6400.t93 109.174
R3235 a_17292_6400.n40 a_17292_6400.t92 109.174
R3236 a_17292_6400.n41 a_17292_6400.t91 109.174
R3237 a_17292_6400.n42 a_17292_6400.t90 109.174
R3238 a_17292_6400.n43 a_17292_6400.t89 109.174
R3239 a_17292_6400.n44 a_17292_6400.t88 109.174
R3240 a_17292_6400.n45 a_17292_6400.t87 109.174
R3241 a_17292_6400.n46 a_17292_6400.t86 109.174
R3242 a_17292_6400.n47 a_17292_6400.t85 109.174
R3243 a_17292_6400.n48 a_17292_6400.t84 109.174
R3244 a_17292_6400.n49 a_17292_6400.t83 109.174
R3245 a_17292_6400.n50 a_17292_6400.t82 109.174
R3246 a_17292_6400.n51 a_17292_6400.t81 109.174
R3247 a_17292_6400.n79 a_17292_6400.t78 109.174
R3248 a_17292_6400.n52 a_17292_6400.t77 109.174
R3249 a_17292_6400.n75 a_17292_6400.t76 109.174
R3250 a_17292_6400.n74 a_17292_6400.t75 109.174
R3251 a_17292_6400.n73 a_17292_6400.t74 109.174
R3252 a_17292_6400.n54 a_17292_6400.t73 109.174
R3253 a_17292_6400.n69 a_17292_6400.t72 109.174
R3254 a_17292_6400.n68 a_17292_6400.t71 109.174
R3255 a_17292_6400.n67 a_17292_6400.t70 109.174
R3256 a_17292_6400.n56 a_17292_6400.t69 109.174
R3257 a_17292_6400.n63 a_17292_6400.t68 109.174
R3258 a_17292_6400.n62 a_17292_6400.t67 109.174
R3259 a_17292_6400.n61 a_17292_6400.t66 109.174
R3260 a_17292_6400.n58 a_17292_6400.t65 109.174
R3261 a_17292_6400.n141 a_17292_6400.n84 18.4942
R3262 a_17292_6400.n143 a_17292_6400.n142 18.4942
R3263 a_17292_6400.n100 a_17292_6400.n97 18.4942
R3264 a_17292_6400.n101 a_17292_6400.n96 18.4942
R3265 a_17292_6400.n102 a_17292_6400.n95 18.4942
R3266 a_17292_6400.n103 a_17292_6400.n94 18.4942
R3267 a_17292_6400.n104 a_17292_6400.n93 18.4942
R3268 a_17292_6400.n105 a_17292_6400.n92 18.4942
R3269 a_17292_6400.n106 a_17292_6400.n91 18.4942
R3270 a_17292_6400.n107 a_17292_6400.n90 18.4942
R3271 a_17292_6400.n108 a_17292_6400.n89 18.4942
R3272 a_17292_6400.n109 a_17292_6400.n88 18.4942
R3273 a_17292_6400.n110 a_17292_6400.n87 18.4942
R3274 a_17292_6400.n111 a_17292_6400.n86 18.4942
R3275 a_17292_6400.n112 a_17292_6400.n85 18.4942
R3276 a_17292_6400.n140 a_17292_6400.n139 18.4942
R3277 a_17292_6400.n138 a_17292_6400.n113 18.4942
R3278 a_17292_6400.n137 a_17292_6400.n136 18.4942
R3279 a_17292_6400.n135 a_17292_6400.n114 18.4942
R3280 a_17292_6400.n134 a_17292_6400.n133 18.4942
R3281 a_17292_6400.n132 a_17292_6400.n115 18.4942
R3282 a_17292_6400.n131 a_17292_6400.n130 18.4942
R3283 a_17292_6400.n129 a_17292_6400.n116 18.4942
R3284 a_17292_6400.n128 a_17292_6400.n127 18.4942
R3285 a_17292_6400.n126 a_17292_6400.n117 18.4942
R3286 a_17292_6400.n125 a_17292_6400.n124 18.4942
R3287 a_17292_6400.n123 a_17292_6400.n118 18.4942
R3288 a_17292_6400.n122 a_17292_6400.n121 18.4942
R3289 a_17292_6400.n80 a_17292_6400.n23 18.4942
R3290 a_17292_6400.n82 a_17292_6400.n81 18.4942
R3291 a_17292_6400.n39 a_17292_6400.n36 18.4942
R3292 a_17292_6400.n40 a_17292_6400.n35 18.4942
R3293 a_17292_6400.n41 a_17292_6400.n34 18.4942
R3294 a_17292_6400.n42 a_17292_6400.n33 18.4942
R3295 a_17292_6400.n43 a_17292_6400.n32 18.4942
R3296 a_17292_6400.n44 a_17292_6400.n31 18.4942
R3297 a_17292_6400.n45 a_17292_6400.n30 18.4942
R3298 a_17292_6400.n46 a_17292_6400.n29 18.4942
R3299 a_17292_6400.n47 a_17292_6400.n28 18.4942
R3300 a_17292_6400.n48 a_17292_6400.n27 18.4942
R3301 a_17292_6400.n49 a_17292_6400.n26 18.4942
R3302 a_17292_6400.n50 a_17292_6400.n25 18.4942
R3303 a_17292_6400.n51 a_17292_6400.n24 18.4942
R3304 a_17292_6400.n79 a_17292_6400.n78 18.4942
R3305 a_17292_6400.n77 a_17292_6400.n52 18.4942
R3306 a_17292_6400.n76 a_17292_6400.n75 18.4942
R3307 a_17292_6400.n74 a_17292_6400.n53 18.4942
R3308 a_17292_6400.n73 a_17292_6400.n72 18.4942
R3309 a_17292_6400.n71 a_17292_6400.n54 18.4942
R3310 a_17292_6400.n70 a_17292_6400.n69 18.4942
R3311 a_17292_6400.n68 a_17292_6400.n55 18.4942
R3312 a_17292_6400.n67 a_17292_6400.n66 18.4942
R3313 a_17292_6400.n65 a_17292_6400.n56 18.4942
R3314 a_17292_6400.n64 a_17292_6400.n63 18.4942
R3315 a_17292_6400.n62 a_17292_6400.n57 18.4942
R3316 a_17292_6400.n61 a_17292_6400.n60 18.4942
R3317 a_17292_6400.n146 a_17292_6400.n145 17.0741
R3318 a_17292_6400.n141 a_17292_6400.n140 11.6805
R3319 a_17292_6400.n142 a_17292_6400.n141 11.6805
R3320 a_17292_6400.n100 a_17292_6400.n99 11.6805
R3321 a_17292_6400.n101 a_17292_6400.n100 11.6805
R3322 a_17292_6400.n102 a_17292_6400.n101 11.6805
R3323 a_17292_6400.n103 a_17292_6400.n102 11.6805
R3324 a_17292_6400.n104 a_17292_6400.n103 11.6805
R3325 a_17292_6400.n105 a_17292_6400.n104 11.6805
R3326 a_17292_6400.n106 a_17292_6400.n105 11.6805
R3327 a_17292_6400.n107 a_17292_6400.n106 11.6805
R3328 a_17292_6400.n108 a_17292_6400.n107 11.6805
R3329 a_17292_6400.n109 a_17292_6400.n108 11.6805
R3330 a_17292_6400.n110 a_17292_6400.n109 11.6805
R3331 a_17292_6400.n111 a_17292_6400.n110 11.6805
R3332 a_17292_6400.n112 a_17292_6400.n111 11.6805
R3333 a_17292_6400.n142 a_17292_6400.n112 11.6805
R3334 a_17292_6400.n140 a_17292_6400.n113 11.6805
R3335 a_17292_6400.n136 a_17292_6400.n113 11.6805
R3336 a_17292_6400.n136 a_17292_6400.n135 11.6805
R3337 a_17292_6400.n135 a_17292_6400.n134 11.6805
R3338 a_17292_6400.n134 a_17292_6400.n115 11.6805
R3339 a_17292_6400.n130 a_17292_6400.n115 11.6805
R3340 a_17292_6400.n130 a_17292_6400.n129 11.6805
R3341 a_17292_6400.n129 a_17292_6400.n128 11.6805
R3342 a_17292_6400.n128 a_17292_6400.n117 11.6805
R3343 a_17292_6400.n124 a_17292_6400.n117 11.6805
R3344 a_17292_6400.n124 a_17292_6400.n123 11.6805
R3345 a_17292_6400.n123 a_17292_6400.n122 11.6805
R3346 a_17292_6400.n122 a_17292_6400.n119 11.6805
R3347 a_17292_6400.n80 a_17292_6400.n79 11.6805
R3348 a_17292_6400.n81 a_17292_6400.n80 11.6805
R3349 a_17292_6400.n39 a_17292_6400.n38 11.6805
R3350 a_17292_6400.n40 a_17292_6400.n39 11.6805
R3351 a_17292_6400.n41 a_17292_6400.n40 11.6805
R3352 a_17292_6400.n42 a_17292_6400.n41 11.6805
R3353 a_17292_6400.n43 a_17292_6400.n42 11.6805
R3354 a_17292_6400.n44 a_17292_6400.n43 11.6805
R3355 a_17292_6400.n45 a_17292_6400.n44 11.6805
R3356 a_17292_6400.n46 a_17292_6400.n45 11.6805
R3357 a_17292_6400.n47 a_17292_6400.n46 11.6805
R3358 a_17292_6400.n48 a_17292_6400.n47 11.6805
R3359 a_17292_6400.n49 a_17292_6400.n48 11.6805
R3360 a_17292_6400.n50 a_17292_6400.n49 11.6805
R3361 a_17292_6400.n51 a_17292_6400.n50 11.6805
R3362 a_17292_6400.n81 a_17292_6400.n51 11.6805
R3363 a_17292_6400.n79 a_17292_6400.n52 11.6805
R3364 a_17292_6400.n75 a_17292_6400.n52 11.6805
R3365 a_17292_6400.n75 a_17292_6400.n74 11.6805
R3366 a_17292_6400.n74 a_17292_6400.n73 11.6805
R3367 a_17292_6400.n73 a_17292_6400.n54 11.6805
R3368 a_17292_6400.n69 a_17292_6400.n54 11.6805
R3369 a_17292_6400.n69 a_17292_6400.n68 11.6805
R3370 a_17292_6400.n68 a_17292_6400.n67 11.6805
R3371 a_17292_6400.n67 a_17292_6400.n56 11.6805
R3372 a_17292_6400.n63 a_17292_6400.n56 11.6805
R3373 a_17292_6400.n63 a_17292_6400.n62 11.6805
R3374 a_17292_6400.n62 a_17292_6400.n61 11.6805
R3375 a_17292_6400.n61 a_17292_6400.n58 11.6805
R3376 a_17292_6400.n145 a_17292_6400.n83 10.9291
R3377 a_17292_6400.n145 a_17292_6400.n144 9.0005
R3378 a_17292_6400.n121 a_17292_6400.n120 7.17687
R3379 a_17292_6400.n98 a_17292_6400.n97 7.17687
R3380 a_17292_6400.n60 a_17292_6400.n59 7.17687
R3381 a_17292_6400.n37 a_17292_6400.n36 7.17687
R3382 a_17292_6400.n146 a_17292_6400.n22 6.5392
R3383 a_17292_6400.n1 a_17292_6400.t12 5.7796
R3384 a_17292_6400.n9 a_17292_6400.t30 5.73764
R3385 a_17292_6400.n147 a_17292_6400.t29 5.59012
R3386 a_17292_6400.n22 a_17292_6400.t16 5.54817
R3387 a_17292_6400.n153 a_17292_6400.n152 5.38537
R3388 a_17292_6400.n1 a_17292_6400.n0 5.38537
R3389 a_17292_6400.n3 a_17292_6400.n2 5.38537
R3390 a_17292_6400.n5 a_17292_6400.n4 5.38537
R3391 a_17292_6400.n7 a_17292_6400.n6 5.38537
R3392 a_17292_6400.n151 a_17292_6400.n150 5.38537
R3393 a_17292_6400.n149 a_17292_6400.n148 5.38537
R3394 a_17292_6400.n9 a_17292_6400.n8 5.32067
R3395 a_17292_6400.n11 a_17292_6400.n10 5.32067
R3396 a_17292_6400.n13 a_17292_6400.n12 5.32067
R3397 a_17292_6400.n15 a_17292_6400.n14 5.32067
R3398 a_17292_6400.n17 a_17292_6400.n16 5.32067
R3399 a_17292_6400.n19 a_17292_6400.n18 5.32067
R3400 a_17292_6400.n21 a_17292_6400.n20 5.32067
R3401 a_17292_6400.n147 a_17292_6400.n146 4.61063
R3402 a_17292_6400.n99 a_17292_6400.n98 4.42851
R3403 a_17292_6400.n120 a_17292_6400.n119 4.42851
R3404 a_17292_6400.n38 a_17292_6400.n37 4.42851
R3405 a_17292_6400.n59 a_17292_6400.n58 4.42851
R3406 a_17292_6400.n8 a_17292_6400.t8 0.228
R3407 a_17292_6400.n8 a_17292_6400.t31 0.228
R3408 a_17292_6400.n10 a_17292_6400.t22 0.228
R3409 a_17292_6400.n10 a_17292_6400.t9 0.228
R3410 a_17292_6400.n12 a_17292_6400.t20 0.228
R3411 a_17292_6400.n12 a_17292_6400.t23 0.228
R3412 a_17292_6400.n14 a_17292_6400.t10 0.228
R3413 a_17292_6400.n14 a_17292_6400.t21 0.228
R3414 a_17292_6400.n16 a_17292_6400.t27 0.228
R3415 a_17292_6400.n16 a_17292_6400.t11 0.228
R3416 a_17292_6400.n18 a_17292_6400.t6 0.228
R3417 a_17292_6400.n18 a_17292_6400.t28 0.228
R3418 a_17292_6400.n20 a_17292_6400.t15 0.228
R3419 a_17292_6400.n20 a_17292_6400.t7 0.228
R3420 a_17292_6400.n153 a_17292_6400.t1 0.20525
R3421 a_17292_6400.t0 a_17292_6400.n153 0.20525
R3422 a_17292_6400.n0 a_17292_6400.t14 0.20525
R3423 a_17292_6400.n0 a_17292_6400.t13 0.20525
R3424 a_17292_6400.n2 a_17292_6400.t18 0.20525
R3425 a_17292_6400.n2 a_17292_6400.t17 0.20525
R3426 a_17292_6400.n4 a_17292_6400.t3 0.20525
R3427 a_17292_6400.n4 a_17292_6400.t19 0.20525
R3428 a_17292_6400.n6 a_17292_6400.t5 0.20525
R3429 a_17292_6400.n6 a_17292_6400.t4 0.20525
R3430 a_17292_6400.n150 a_17292_6400.t24 0.20525
R3431 a_17292_6400.n150 a_17292_6400.t2 0.20525
R3432 a_17292_6400.n148 a_17292_6400.t26 0.20525
R3433 a_17292_6400.n148 a_17292_6400.t25 0.20525
R3434 a_17292_6400.n149 a_17292_6400.n147 0.189974
R3435 a_17292_6400.n151 a_17292_6400.n149 0.189974
R3436 a_17292_6400.n152 a_17292_6400.n151 0.189974
R3437 a_17292_6400.n152 a_17292_6400.n7 0.189974
R3438 a_17292_6400.n7 a_17292_6400.n5 0.189974
R3439 a_17292_6400.n5 a_17292_6400.n3 0.189974
R3440 a_17292_6400.n3 a_17292_6400.n1 0.189974
R3441 a_17292_6400.n22 a_17292_6400.n21 0.189974
R3442 a_17292_6400.n21 a_17292_6400.n19 0.189974
R3443 a_17292_6400.n19 a_17292_6400.n17 0.189974
R3444 a_17292_6400.n17 a_17292_6400.n15 0.189974
R3445 a_17292_6400.n15 a_17292_6400.n13 0.189974
R3446 a_17292_6400.n13 a_17292_6400.n11 0.189974
R3447 a_17292_6400.n11 a_17292_6400.n9 0.189974
R3448 a_17292_6400.n139 a_17292_6400.n84 0.1205
R3449 a_17292_6400.n139 a_17292_6400.n138 0.1205
R3450 a_17292_6400.n138 a_17292_6400.n137 0.1205
R3451 a_17292_6400.n137 a_17292_6400.n114 0.1205
R3452 a_17292_6400.n133 a_17292_6400.n114 0.1205
R3453 a_17292_6400.n133 a_17292_6400.n132 0.1205
R3454 a_17292_6400.n132 a_17292_6400.n131 0.1205
R3455 a_17292_6400.n131 a_17292_6400.n116 0.1205
R3456 a_17292_6400.n127 a_17292_6400.n116 0.1205
R3457 a_17292_6400.n127 a_17292_6400.n126 0.1205
R3458 a_17292_6400.n126 a_17292_6400.n125 0.1205
R3459 a_17292_6400.n125 a_17292_6400.n118 0.1205
R3460 a_17292_6400.n121 a_17292_6400.n118 0.1205
R3461 a_17292_6400.n97 a_17292_6400.n96 0.1205
R3462 a_17292_6400.n96 a_17292_6400.n95 0.1205
R3463 a_17292_6400.n95 a_17292_6400.n94 0.1205
R3464 a_17292_6400.n94 a_17292_6400.n93 0.1205
R3465 a_17292_6400.n93 a_17292_6400.n92 0.1205
R3466 a_17292_6400.n92 a_17292_6400.n91 0.1205
R3467 a_17292_6400.n91 a_17292_6400.n90 0.1205
R3468 a_17292_6400.n90 a_17292_6400.n89 0.1205
R3469 a_17292_6400.n89 a_17292_6400.n88 0.1205
R3470 a_17292_6400.n88 a_17292_6400.n87 0.1205
R3471 a_17292_6400.n87 a_17292_6400.n86 0.1205
R3472 a_17292_6400.n86 a_17292_6400.n85 0.1205
R3473 a_17292_6400.n143 a_17292_6400.n85 0.1205
R3474 a_17292_6400.n78 a_17292_6400.n23 0.1205
R3475 a_17292_6400.n78 a_17292_6400.n77 0.1205
R3476 a_17292_6400.n77 a_17292_6400.n76 0.1205
R3477 a_17292_6400.n76 a_17292_6400.n53 0.1205
R3478 a_17292_6400.n72 a_17292_6400.n53 0.1205
R3479 a_17292_6400.n72 a_17292_6400.n71 0.1205
R3480 a_17292_6400.n71 a_17292_6400.n70 0.1205
R3481 a_17292_6400.n70 a_17292_6400.n55 0.1205
R3482 a_17292_6400.n66 a_17292_6400.n55 0.1205
R3483 a_17292_6400.n66 a_17292_6400.n65 0.1205
R3484 a_17292_6400.n65 a_17292_6400.n64 0.1205
R3485 a_17292_6400.n64 a_17292_6400.n57 0.1205
R3486 a_17292_6400.n60 a_17292_6400.n57 0.1205
R3487 a_17292_6400.n36 a_17292_6400.n35 0.1205
R3488 a_17292_6400.n35 a_17292_6400.n34 0.1205
R3489 a_17292_6400.n34 a_17292_6400.n33 0.1205
R3490 a_17292_6400.n33 a_17292_6400.n32 0.1205
R3491 a_17292_6400.n32 a_17292_6400.n31 0.1205
R3492 a_17292_6400.n31 a_17292_6400.n30 0.1205
R3493 a_17292_6400.n30 a_17292_6400.n29 0.1205
R3494 a_17292_6400.n29 a_17292_6400.n28 0.1205
R3495 a_17292_6400.n28 a_17292_6400.n27 0.1205
R3496 a_17292_6400.n27 a_17292_6400.n26 0.1205
R3497 a_17292_6400.n26 a_17292_6400.n25 0.1205
R3498 a_17292_6400.n25 a_17292_6400.n24 0.1205
R3499 a_17292_6400.n82 a_17292_6400.n24 0.1205
R3500 a_17292_6400.n144 a_17292_6400.n84 0.0485
R3501 a_17292_6400.n144 a_17292_6400.n143 0.0485
R3502 a_17292_6400.n83 a_17292_6400.n23 0.0485
R3503 a_17292_6400.n83 a_17292_6400.n82 0.0485
R3504 a_14540_6400.n35 a_14540_6400.t31 113.632
R3505 a_14540_6400.n45 a_14540_6400.t16 113.632
R3506 a_14540_6400.n6 a_14540_6400.t47 113.632
R3507 a_14540_6400.n16 a_14540_6400.t32 113.632
R3508 a_14540_6400.n54 a_14540_6400.t23 109.174
R3509 a_14540_6400.n55 a_14540_6400.t24 109.174
R3510 a_14540_6400.n36 a_14540_6400.t30 109.174
R3511 a_14540_6400.n37 a_14540_6400.t29 109.174
R3512 a_14540_6400.n38 a_14540_6400.t28 109.174
R3513 a_14540_6400.n39 a_14540_6400.t27 109.174
R3514 a_14540_6400.n40 a_14540_6400.t26 109.174
R3515 a_14540_6400.n41 a_14540_6400.t25 109.174
R3516 a_14540_6400.n53 a_14540_6400.t22 109.174
R3517 a_14540_6400.n42 a_14540_6400.t21 109.174
R3518 a_14540_6400.n49 a_14540_6400.t20 109.174
R3519 a_14540_6400.n48 a_14540_6400.t19 109.174
R3520 a_14540_6400.n47 a_14540_6400.t18 109.174
R3521 a_14540_6400.n44 a_14540_6400.t17 109.174
R3522 a_14540_6400.n25 a_14540_6400.t39 109.174
R3523 a_14540_6400.n26 a_14540_6400.t40 109.174
R3524 a_14540_6400.n7 a_14540_6400.t46 109.174
R3525 a_14540_6400.n8 a_14540_6400.t45 109.174
R3526 a_14540_6400.n9 a_14540_6400.t44 109.174
R3527 a_14540_6400.n10 a_14540_6400.t43 109.174
R3528 a_14540_6400.n11 a_14540_6400.t42 109.174
R3529 a_14540_6400.n12 a_14540_6400.t41 109.174
R3530 a_14540_6400.n24 a_14540_6400.t38 109.174
R3531 a_14540_6400.n13 a_14540_6400.t37 109.174
R3532 a_14540_6400.n20 a_14540_6400.t36 109.174
R3533 a_14540_6400.n19 a_14540_6400.t35 109.174
R3534 a_14540_6400.n18 a_14540_6400.t34 109.174
R3535 a_14540_6400.n15 a_14540_6400.t33 109.174
R3536 a_14540_6400.n54 a_14540_6400.n29 18.4942
R3537 a_14540_6400.n56 a_14540_6400.n55 18.4942
R3538 a_14540_6400.n37 a_14540_6400.n34 18.4942
R3539 a_14540_6400.n38 a_14540_6400.n33 18.4942
R3540 a_14540_6400.n39 a_14540_6400.n32 18.4942
R3541 a_14540_6400.n40 a_14540_6400.n31 18.4942
R3542 a_14540_6400.n41 a_14540_6400.n30 18.4942
R3543 a_14540_6400.n53 a_14540_6400.n52 18.4942
R3544 a_14540_6400.n51 a_14540_6400.n42 18.4942
R3545 a_14540_6400.n50 a_14540_6400.n49 18.4942
R3546 a_14540_6400.n48 a_14540_6400.n43 18.4942
R3547 a_14540_6400.n47 a_14540_6400.n46 18.4942
R3548 a_14540_6400.n25 a_14540_6400.n0 18.4942
R3549 a_14540_6400.n27 a_14540_6400.n26 18.4942
R3550 a_14540_6400.n8 a_14540_6400.n5 18.4942
R3551 a_14540_6400.n9 a_14540_6400.n4 18.4942
R3552 a_14540_6400.n10 a_14540_6400.n3 18.4942
R3553 a_14540_6400.n11 a_14540_6400.n2 18.4942
R3554 a_14540_6400.n12 a_14540_6400.n1 18.4942
R3555 a_14540_6400.n24 a_14540_6400.n23 18.4942
R3556 a_14540_6400.n22 a_14540_6400.n13 18.4942
R3557 a_14540_6400.n21 a_14540_6400.n20 18.4942
R3558 a_14540_6400.n19 a_14540_6400.n14 18.4942
R3559 a_14540_6400.n18 a_14540_6400.n17 18.4942
R3560 a_14540_6400.n66 a_14540_6400.n58 14.1358
R3561 a_14540_6400.n54 a_14540_6400.n53 11.6805
R3562 a_14540_6400.n55 a_14540_6400.n54 11.6805
R3563 a_14540_6400.n37 a_14540_6400.n36 11.6805
R3564 a_14540_6400.n38 a_14540_6400.n37 11.6805
R3565 a_14540_6400.n39 a_14540_6400.n38 11.6805
R3566 a_14540_6400.n40 a_14540_6400.n39 11.6805
R3567 a_14540_6400.n41 a_14540_6400.n40 11.6805
R3568 a_14540_6400.n55 a_14540_6400.n41 11.6805
R3569 a_14540_6400.n53 a_14540_6400.n42 11.6805
R3570 a_14540_6400.n49 a_14540_6400.n42 11.6805
R3571 a_14540_6400.n49 a_14540_6400.n48 11.6805
R3572 a_14540_6400.n48 a_14540_6400.n47 11.6805
R3573 a_14540_6400.n47 a_14540_6400.n44 11.6805
R3574 a_14540_6400.n25 a_14540_6400.n24 11.6805
R3575 a_14540_6400.n26 a_14540_6400.n25 11.6805
R3576 a_14540_6400.n8 a_14540_6400.n7 11.6805
R3577 a_14540_6400.n9 a_14540_6400.n8 11.6805
R3578 a_14540_6400.n10 a_14540_6400.n9 11.6805
R3579 a_14540_6400.n11 a_14540_6400.n10 11.6805
R3580 a_14540_6400.n12 a_14540_6400.n11 11.6805
R3581 a_14540_6400.n26 a_14540_6400.n12 11.6805
R3582 a_14540_6400.n24 a_14540_6400.n13 11.6805
R3583 a_14540_6400.n20 a_14540_6400.n13 11.6805
R3584 a_14540_6400.n20 a_14540_6400.n19 11.6805
R3585 a_14540_6400.n19 a_14540_6400.n18 11.6805
R3586 a_14540_6400.n18 a_14540_6400.n15 11.6805
R3587 a_14540_6400.n58 a_14540_6400.n28 10.688
R3588 a_14540_6400.n58 a_14540_6400.n57 9.24157
R3589 a_14540_6400.n46 a_14540_6400.n45 7.17687
R3590 a_14540_6400.n35 a_14540_6400.n34 7.17687
R3591 a_14540_6400.n17 a_14540_6400.n16 7.17687
R3592 a_14540_6400.n6 a_14540_6400.n5 7.17687
R3593 a_14540_6400.n67 a_14540_6400.n66 6.5392
R3594 a_14540_6400.n60 a_14540_6400.t11 5.7796
R3595 a_14540_6400.n72 a_14540_6400.t7 5.73764
R3596 a_14540_6400.n65 a_14540_6400.t6 5.59012
R3597 a_14540_6400.n67 a_14540_6400.t8 5.54817
R3598 a_14540_6400.n60 a_14540_6400.n59 5.38537
R3599 a_14540_6400.n62 a_14540_6400.n61 5.38537
R3600 a_14540_6400.n64 a_14540_6400.n63 5.38537
R3601 a_14540_6400.n73 a_14540_6400.n72 5.32067
R3602 a_14540_6400.n71 a_14540_6400.n70 5.32067
R3603 a_14540_6400.n69 a_14540_6400.n68 5.32067
R3604 a_14540_6400.n66 a_14540_6400.n65 4.61063
R3605 a_14540_6400.n36 a_14540_6400.n35 4.42851
R3606 a_14540_6400.n45 a_14540_6400.n44 4.42851
R3607 a_14540_6400.n7 a_14540_6400.n6 4.42851
R3608 a_14540_6400.n16 a_14540_6400.n15 4.42851
R3609 a_14540_6400.n73 a_14540_6400.t1 0.228
R3610 a_14540_6400.t0 a_14540_6400.n73 0.228
R3611 a_14540_6400.n70 a_14540_6400.t3 0.228
R3612 a_14540_6400.n70 a_14540_6400.t2 0.228
R3613 a_14540_6400.n68 a_14540_6400.t5 0.228
R3614 a_14540_6400.n68 a_14540_6400.t4 0.228
R3615 a_14540_6400.n59 a_14540_6400.t13 0.20525
R3616 a_14540_6400.n59 a_14540_6400.t12 0.20525
R3617 a_14540_6400.n61 a_14540_6400.t15 0.20525
R3618 a_14540_6400.n61 a_14540_6400.t14 0.20525
R3619 a_14540_6400.n63 a_14540_6400.t10 0.20525
R3620 a_14540_6400.n63 a_14540_6400.t9 0.20525
R3621 a_14540_6400.n69 a_14540_6400.n67 0.189974
R3622 a_14540_6400.n71 a_14540_6400.n69 0.189974
R3623 a_14540_6400.n72 a_14540_6400.n71 0.189974
R3624 a_14540_6400.n65 a_14540_6400.n64 0.189974
R3625 a_14540_6400.n64 a_14540_6400.n62 0.189974
R3626 a_14540_6400.n62 a_14540_6400.n60 0.189974
R3627 a_14540_6400.n52 a_14540_6400.n29 0.1205
R3628 a_14540_6400.n52 a_14540_6400.n51 0.1205
R3629 a_14540_6400.n51 a_14540_6400.n50 0.1205
R3630 a_14540_6400.n50 a_14540_6400.n43 0.1205
R3631 a_14540_6400.n46 a_14540_6400.n43 0.1205
R3632 a_14540_6400.n34 a_14540_6400.n33 0.1205
R3633 a_14540_6400.n33 a_14540_6400.n32 0.1205
R3634 a_14540_6400.n32 a_14540_6400.n31 0.1205
R3635 a_14540_6400.n31 a_14540_6400.n30 0.1205
R3636 a_14540_6400.n56 a_14540_6400.n30 0.1205
R3637 a_14540_6400.n23 a_14540_6400.n0 0.1205
R3638 a_14540_6400.n23 a_14540_6400.n22 0.1205
R3639 a_14540_6400.n22 a_14540_6400.n21 0.1205
R3640 a_14540_6400.n21 a_14540_6400.n14 0.1205
R3641 a_14540_6400.n17 a_14540_6400.n14 0.1205
R3642 a_14540_6400.n5 a_14540_6400.n4 0.1205
R3643 a_14540_6400.n4 a_14540_6400.n3 0.1205
R3644 a_14540_6400.n3 a_14540_6400.n2 0.1205
R3645 a_14540_6400.n2 a_14540_6400.n1 0.1205
R3646 a_14540_6400.n27 a_14540_6400.n1 0.1205
R3647 a_14540_6400.n57 a_14540_6400.n29 0.0485
R3648 a_14540_6400.n57 a_14540_6400.n56 0.0485
R3649 a_14540_6400.n28 a_14540_6400.n0 0.0485
R3650 a_14540_6400.n28 a_14540_6400.n27 0.0485
R3651 a_6924_6400.n18 a_6924_6400.t15 113.632
R3652 a_6924_6400.n22 a_6924_6400.t8 113.632
R3653 a_6924_6400.n5 a_6924_6400.t23 113.632
R3654 a_6924_6400.n9 a_6924_6400.t16 113.632
R3655 a_6924_6400.n25 a_6924_6400.t11 109.174
R3656 a_6924_6400.n26 a_6924_6400.t12 109.174
R3657 a_6924_6400.n19 a_6924_6400.t14 109.174
R3658 a_6924_6400.n20 a_6924_6400.t13 109.174
R3659 a_6924_6400.n24 a_6924_6400.t10 109.174
R3660 a_6924_6400.n21 a_6924_6400.t9 109.174
R3661 a_6924_6400.n12 a_6924_6400.t19 109.174
R3662 a_6924_6400.n13 a_6924_6400.t20 109.174
R3663 a_6924_6400.n6 a_6924_6400.t22 109.174
R3664 a_6924_6400.n7 a_6924_6400.t21 109.174
R3665 a_6924_6400.n11 a_6924_6400.t18 109.174
R3666 a_6924_6400.n8 a_6924_6400.t17 109.174
R3667 a_6924_6400.n25 a_6924_6400.n16 18.4942
R3668 a_6924_6400.n27 a_6924_6400.n26 18.4942
R3669 a_6924_6400.n20 a_6924_6400.n17 18.4942
R3670 a_6924_6400.n24 a_6924_6400.n23 18.4942
R3671 a_6924_6400.n12 a_6924_6400.n3 18.4942
R3672 a_6924_6400.n14 a_6924_6400.n13 18.4942
R3673 a_6924_6400.n7 a_6924_6400.n4 18.4942
R3674 a_6924_6400.n11 a_6924_6400.n10 18.4942
R3675 a_6924_6400.n30 a_6924_6400.n29 17.593
R3676 a_6924_6400.n25 a_6924_6400.n24 11.6805
R3677 a_6924_6400.n26 a_6924_6400.n25 11.6805
R3678 a_6924_6400.n20 a_6924_6400.n19 11.6805
R3679 a_6924_6400.n26 a_6924_6400.n20 11.6805
R3680 a_6924_6400.n24 a_6924_6400.n21 11.6805
R3681 a_6924_6400.n12 a_6924_6400.n11 11.6805
R3682 a_6924_6400.n13 a_6924_6400.n12 11.6805
R3683 a_6924_6400.n7 a_6924_6400.n6 11.6805
R3684 a_6924_6400.n13 a_6924_6400.n7 11.6805
R3685 a_6924_6400.n11 a_6924_6400.n8 11.6805
R3686 a_6924_6400.n29 a_6924_6400.n15 10.013
R3687 a_6924_6400.n29 a_6924_6400.n28 9.91657
R3688 a_6924_6400.n23 a_6924_6400.n22 7.17687
R3689 a_6924_6400.n18 a_6924_6400.n17 7.17687
R3690 a_6924_6400.n10 a_6924_6400.n9 7.17687
R3691 a_6924_6400.n5 a_6924_6400.n4 7.17687
R3692 a_6924_6400.n30 a_6924_6400.n2 6.5392
R3693 a_6924_6400.t3 a_6924_6400.n33 5.7796
R3694 a_6924_6400.n1 a_6924_6400.t7 5.73764
R3695 a_6924_6400.n31 a_6924_6400.t0 5.59012
R3696 a_6924_6400.n2 a_6924_6400.t4 5.54817
R3697 a_6924_6400.n33 a_6924_6400.n32 5.38537
R3698 a_6924_6400.n1 a_6924_6400.n0 5.32067
R3699 a_6924_6400.n31 a_6924_6400.n30 4.61063
R3700 a_6924_6400.n19 a_6924_6400.n18 4.42851
R3701 a_6924_6400.n22 a_6924_6400.n21 4.42851
R3702 a_6924_6400.n6 a_6924_6400.n5 4.42851
R3703 a_6924_6400.n9 a_6924_6400.n8 4.42851
R3704 a_6924_6400.n0 a_6924_6400.t5 0.228
R3705 a_6924_6400.n0 a_6924_6400.t6 0.228
R3706 a_6924_6400.n32 a_6924_6400.t1 0.20525
R3707 a_6924_6400.n32 a_6924_6400.t2 0.20525
R3708 a_6924_6400.n33 a_6924_6400.n31 0.189974
R3709 a_6924_6400.n2 a_6924_6400.n1 0.189974
R3710 a_6924_6400.n23 a_6924_6400.n16 0.1205
R3711 a_6924_6400.n27 a_6924_6400.n17 0.1205
R3712 a_6924_6400.n10 a_6924_6400.n3 0.1205
R3713 a_6924_6400.n14 a_6924_6400.n4 0.1205
R3714 a_6924_6400.n28 a_6924_6400.n16 0.0485
R3715 a_6924_6400.n28 a_6924_6400.n27 0.0485
R3716 a_6924_6400.n15 a_6924_6400.n3 0.0485
R3717 a_6924_6400.n15 a_6924_6400.n14 0.0485
R3718 a_4812_6400.n18 a_4812_6400.t15 113.632
R3719 a_4812_6400.n22 a_4812_6400.t8 113.632
R3720 a_4812_6400.n5 a_4812_6400.t23 113.632
R3721 a_4812_6400.n9 a_4812_6400.t16 113.632
R3722 a_4812_6400.n25 a_4812_6400.t11 109.174
R3723 a_4812_6400.n26 a_4812_6400.t12 109.174
R3724 a_4812_6400.n19 a_4812_6400.t14 109.174
R3725 a_4812_6400.n20 a_4812_6400.t13 109.174
R3726 a_4812_6400.n24 a_4812_6400.t10 109.174
R3727 a_4812_6400.n21 a_4812_6400.t9 109.174
R3728 a_4812_6400.n12 a_4812_6400.t19 109.174
R3729 a_4812_6400.n13 a_4812_6400.t20 109.174
R3730 a_4812_6400.n6 a_4812_6400.t22 109.174
R3731 a_4812_6400.n7 a_4812_6400.t21 109.174
R3732 a_4812_6400.n11 a_4812_6400.t18 109.174
R3733 a_4812_6400.n8 a_4812_6400.t17 109.174
R3734 a_4812_6400.n25 a_4812_6400.n16 18.4942
R3735 a_4812_6400.n27 a_4812_6400.n26 18.4942
R3736 a_4812_6400.n20 a_4812_6400.n17 18.4942
R3737 a_4812_6400.n24 a_4812_6400.n23 18.4942
R3738 a_4812_6400.n12 a_4812_6400.n3 18.4942
R3739 a_4812_6400.n14 a_4812_6400.n13 18.4942
R3740 a_4812_6400.n7 a_4812_6400.n4 18.4942
R3741 a_4812_6400.n11 a_4812_6400.n10 18.4942
R3742 a_4812_6400.n30 a_4812_6400.n29 17.3044
R3743 a_4812_6400.n25 a_4812_6400.n24 11.6805
R3744 a_4812_6400.n26 a_4812_6400.n25 11.6805
R3745 a_4812_6400.n20 a_4812_6400.n19 11.6805
R3746 a_4812_6400.n26 a_4812_6400.n20 11.6805
R3747 a_4812_6400.n24 a_4812_6400.n21 11.6805
R3748 a_4812_6400.n12 a_4812_6400.n11 11.6805
R3749 a_4812_6400.n13 a_4812_6400.n12 11.6805
R3750 a_4812_6400.n7 a_4812_6400.n6 11.6805
R3751 a_4812_6400.n13 a_4812_6400.n7 11.6805
R3752 a_4812_6400.n11 a_4812_6400.n8 11.6805
R3753 a_4812_6400.n29 a_4812_6400.n15 10.3505
R3754 a_4812_6400.n29 a_4812_6400.n28 9.57907
R3755 a_4812_6400.n23 a_4812_6400.n22 7.17687
R3756 a_4812_6400.n18 a_4812_6400.n17 7.17687
R3757 a_4812_6400.n10 a_4812_6400.n9 7.17687
R3758 a_4812_6400.n5 a_4812_6400.n4 7.17687
R3759 a_4812_6400.n30 a_4812_6400.n2 6.5392
R3760 a_4812_6400.t3 a_4812_6400.n33 5.7796
R3761 a_4812_6400.n1 a_4812_6400.t7 5.73764
R3762 a_4812_6400.n31 a_4812_6400.t0 5.59012
R3763 a_4812_6400.n2 a_4812_6400.t4 5.54817
R3764 a_4812_6400.n33 a_4812_6400.n32 5.38537
R3765 a_4812_6400.n1 a_4812_6400.n0 5.32067
R3766 a_4812_6400.n31 a_4812_6400.n30 4.61063
R3767 a_4812_6400.n19 a_4812_6400.n18 4.42851
R3768 a_4812_6400.n22 a_4812_6400.n21 4.42851
R3769 a_4812_6400.n6 a_4812_6400.n5 4.42851
R3770 a_4812_6400.n9 a_4812_6400.n8 4.42851
R3771 a_4812_6400.n0 a_4812_6400.t5 0.228
R3772 a_4812_6400.n0 a_4812_6400.t6 0.228
R3773 a_4812_6400.n32 a_4812_6400.t1 0.20525
R3774 a_4812_6400.n32 a_4812_6400.t2 0.20525
R3775 a_4812_6400.n33 a_4812_6400.n31 0.189974
R3776 a_4812_6400.n2 a_4812_6400.n1 0.189974
R3777 a_4812_6400.n23 a_4812_6400.n16 0.1205
R3778 a_4812_6400.n27 a_4812_6400.n17 0.1205
R3779 a_4812_6400.n10 a_4812_6400.n3 0.1205
R3780 a_4812_6400.n14 a_4812_6400.n4 0.1205
R3781 a_4812_6400.n28 a_4812_6400.n16 0.0485
R3782 a_4812_6400.n28 a_4812_6400.n27 0.0485
R3783 a_4812_6400.n15 a_4812_6400.n3 0.0485
R3784 a_4812_6400.n15 a_4812_6400.n14 0.0485
R3785 a_2700_6400.n18 a_2700_6400.t15 113.632
R3786 a_2700_6400.n22 a_2700_6400.t8 113.632
R3787 a_2700_6400.n5 a_2700_6400.t23 113.632
R3788 a_2700_6400.n9 a_2700_6400.t16 113.632
R3789 a_2700_6400.n25 a_2700_6400.t11 109.174
R3790 a_2700_6400.n26 a_2700_6400.t12 109.174
R3791 a_2700_6400.n19 a_2700_6400.t14 109.174
R3792 a_2700_6400.n20 a_2700_6400.t13 109.174
R3793 a_2700_6400.n24 a_2700_6400.t10 109.174
R3794 a_2700_6400.n21 a_2700_6400.t9 109.174
R3795 a_2700_6400.n12 a_2700_6400.t19 109.174
R3796 a_2700_6400.n13 a_2700_6400.t20 109.174
R3797 a_2700_6400.n6 a_2700_6400.t22 109.174
R3798 a_2700_6400.n7 a_2700_6400.t21 109.174
R3799 a_2700_6400.n11 a_2700_6400.t18 109.174
R3800 a_2700_6400.n8 a_2700_6400.t17 109.174
R3801 a_2700_6400.n25 a_2700_6400.n16 18.4942
R3802 a_2700_6400.n27 a_2700_6400.n26 18.4942
R3803 a_2700_6400.n20 a_2700_6400.n17 18.4942
R3804 a_2700_6400.n24 a_2700_6400.n23 18.4942
R3805 a_2700_6400.n12 a_2700_6400.n3 18.4942
R3806 a_2700_6400.n14 a_2700_6400.n13 18.4942
R3807 a_2700_6400.n7 a_2700_6400.n4 18.4942
R3808 a_2700_6400.n11 a_2700_6400.n10 18.4942
R3809 a_2700_6400.n30 a_2700_6400.n29 17.0158
R3810 a_2700_6400.n25 a_2700_6400.n24 11.6805
R3811 a_2700_6400.n26 a_2700_6400.n25 11.6805
R3812 a_2700_6400.n20 a_2700_6400.n19 11.6805
R3813 a_2700_6400.n26 a_2700_6400.n20 11.6805
R3814 a_2700_6400.n24 a_2700_6400.n21 11.6805
R3815 a_2700_6400.n12 a_2700_6400.n11 11.6805
R3816 a_2700_6400.n13 a_2700_6400.n12 11.6805
R3817 a_2700_6400.n7 a_2700_6400.n6 11.6805
R3818 a_2700_6400.n13 a_2700_6400.n7 11.6805
R3819 a_2700_6400.n11 a_2700_6400.n8 11.6805
R3820 a_2700_6400.n29 a_2700_6400.n15 10.688
R3821 a_2700_6400.n29 a_2700_6400.n28 9.24157
R3822 a_2700_6400.n23 a_2700_6400.n22 7.17687
R3823 a_2700_6400.n18 a_2700_6400.n17 7.17687
R3824 a_2700_6400.n10 a_2700_6400.n9 7.17687
R3825 a_2700_6400.n5 a_2700_6400.n4 7.17687
R3826 a_2700_6400.n30 a_2700_6400.n2 6.5392
R3827 a_2700_6400.t3 a_2700_6400.n33 5.7796
R3828 a_2700_6400.n1 a_2700_6400.t7 5.73764
R3829 a_2700_6400.n31 a_2700_6400.t0 5.59012
R3830 a_2700_6400.n2 a_2700_6400.t4 5.54817
R3831 a_2700_6400.n33 a_2700_6400.n32 5.38537
R3832 a_2700_6400.n1 a_2700_6400.n0 5.32067
R3833 a_2700_6400.n31 a_2700_6400.n30 4.61063
R3834 a_2700_6400.n19 a_2700_6400.n18 4.42851
R3835 a_2700_6400.n22 a_2700_6400.n21 4.42851
R3836 a_2700_6400.n6 a_2700_6400.n5 4.42851
R3837 a_2700_6400.n9 a_2700_6400.n8 4.42851
R3838 a_2700_6400.n0 a_2700_6400.t5 0.228
R3839 a_2700_6400.n0 a_2700_6400.t6 0.228
R3840 a_2700_6400.n32 a_2700_6400.t1 0.20525
R3841 a_2700_6400.n32 a_2700_6400.t2 0.20525
R3842 a_2700_6400.n33 a_2700_6400.n31 0.189974
R3843 a_2700_6400.n2 a_2700_6400.n1 0.189974
R3844 a_2700_6400.n23 a_2700_6400.n16 0.1205
R3845 a_2700_6400.n27 a_2700_6400.n17 0.1205
R3846 a_2700_6400.n10 a_2700_6400.n3 0.1205
R3847 a_2700_6400.n14 a_2700_6400.n4 0.1205
R3848 a_2700_6400.n28 a_2700_6400.n16 0.0485
R3849 a_2700_6400.n28 a_2700_6400.n27 0.0485
R3850 a_2700_6400.n15 a_2700_6400.n3 0.0485
R3851 a_2700_6400.n15 a_2700_6400.n14 0.0485
R3852 a_21324_41600.n165 a_21324_41600.t127 113.632
R3853 a_21324_41600.n211 a_21324_41600.t64 113.632
R3854 a_21324_41600.n40 a_21324_41600.t191 113.632
R3855 a_21324_41600.n86 a_21324_41600.t128 113.632
R3856 a_21324_41600.n256 a_21324_41600.t95 109.174
R3857 a_21324_41600.n257 a_21324_41600.t96 109.174
R3858 a_21324_41600.n166 a_21324_41600.t126 109.174
R3859 a_21324_41600.n167 a_21324_41600.t125 109.174
R3860 a_21324_41600.n168 a_21324_41600.t124 109.174
R3861 a_21324_41600.n169 a_21324_41600.t123 109.174
R3862 a_21324_41600.n170 a_21324_41600.t122 109.174
R3863 a_21324_41600.n171 a_21324_41600.t121 109.174
R3864 a_21324_41600.n172 a_21324_41600.t120 109.174
R3865 a_21324_41600.n173 a_21324_41600.t119 109.174
R3866 a_21324_41600.n174 a_21324_41600.t118 109.174
R3867 a_21324_41600.n175 a_21324_41600.t117 109.174
R3868 a_21324_41600.n176 a_21324_41600.t116 109.174
R3869 a_21324_41600.n177 a_21324_41600.t115 109.174
R3870 a_21324_41600.n178 a_21324_41600.t114 109.174
R3871 a_21324_41600.n179 a_21324_41600.t113 109.174
R3872 a_21324_41600.n180 a_21324_41600.t112 109.174
R3873 a_21324_41600.n181 a_21324_41600.t111 109.174
R3874 a_21324_41600.n182 a_21324_41600.t110 109.174
R3875 a_21324_41600.n183 a_21324_41600.t109 109.174
R3876 a_21324_41600.n184 a_21324_41600.t108 109.174
R3877 a_21324_41600.n185 a_21324_41600.t107 109.174
R3878 a_21324_41600.n186 a_21324_41600.t106 109.174
R3879 a_21324_41600.n187 a_21324_41600.t105 109.174
R3880 a_21324_41600.n188 a_21324_41600.t104 109.174
R3881 a_21324_41600.n189 a_21324_41600.t103 109.174
R3882 a_21324_41600.n190 a_21324_41600.t102 109.174
R3883 a_21324_41600.n191 a_21324_41600.t101 109.174
R3884 a_21324_41600.n192 a_21324_41600.t100 109.174
R3885 a_21324_41600.n193 a_21324_41600.t99 109.174
R3886 a_21324_41600.n194 a_21324_41600.t98 109.174
R3887 a_21324_41600.n195 a_21324_41600.t97 109.174
R3888 a_21324_41600.n255 a_21324_41600.t94 109.174
R3889 a_21324_41600.n196 a_21324_41600.t93 109.174
R3890 a_21324_41600.n251 a_21324_41600.t92 109.174
R3891 a_21324_41600.n250 a_21324_41600.t91 109.174
R3892 a_21324_41600.n249 a_21324_41600.t90 109.174
R3893 a_21324_41600.n198 a_21324_41600.t89 109.174
R3894 a_21324_41600.n245 a_21324_41600.t88 109.174
R3895 a_21324_41600.n244 a_21324_41600.t87 109.174
R3896 a_21324_41600.n243 a_21324_41600.t86 109.174
R3897 a_21324_41600.n200 a_21324_41600.t85 109.174
R3898 a_21324_41600.n239 a_21324_41600.t84 109.174
R3899 a_21324_41600.n238 a_21324_41600.t83 109.174
R3900 a_21324_41600.n237 a_21324_41600.t82 109.174
R3901 a_21324_41600.n202 a_21324_41600.t81 109.174
R3902 a_21324_41600.n233 a_21324_41600.t80 109.174
R3903 a_21324_41600.n232 a_21324_41600.t79 109.174
R3904 a_21324_41600.n231 a_21324_41600.t78 109.174
R3905 a_21324_41600.n204 a_21324_41600.t77 109.174
R3906 a_21324_41600.n227 a_21324_41600.t76 109.174
R3907 a_21324_41600.n226 a_21324_41600.t75 109.174
R3908 a_21324_41600.n225 a_21324_41600.t74 109.174
R3909 a_21324_41600.n206 a_21324_41600.t73 109.174
R3910 a_21324_41600.n221 a_21324_41600.t72 109.174
R3911 a_21324_41600.n220 a_21324_41600.t71 109.174
R3912 a_21324_41600.n219 a_21324_41600.t70 109.174
R3913 a_21324_41600.n208 a_21324_41600.t69 109.174
R3914 a_21324_41600.n215 a_21324_41600.t68 109.174
R3915 a_21324_41600.n214 a_21324_41600.t67 109.174
R3916 a_21324_41600.n213 a_21324_41600.t66 109.174
R3917 a_21324_41600.n210 a_21324_41600.t65 109.174
R3918 a_21324_41600.n131 a_21324_41600.t159 109.174
R3919 a_21324_41600.n132 a_21324_41600.t160 109.174
R3920 a_21324_41600.n41 a_21324_41600.t190 109.174
R3921 a_21324_41600.n42 a_21324_41600.t189 109.174
R3922 a_21324_41600.n43 a_21324_41600.t188 109.174
R3923 a_21324_41600.n44 a_21324_41600.t187 109.174
R3924 a_21324_41600.n45 a_21324_41600.t186 109.174
R3925 a_21324_41600.n46 a_21324_41600.t185 109.174
R3926 a_21324_41600.n47 a_21324_41600.t184 109.174
R3927 a_21324_41600.n48 a_21324_41600.t183 109.174
R3928 a_21324_41600.n49 a_21324_41600.t182 109.174
R3929 a_21324_41600.n50 a_21324_41600.t181 109.174
R3930 a_21324_41600.n51 a_21324_41600.t180 109.174
R3931 a_21324_41600.n52 a_21324_41600.t179 109.174
R3932 a_21324_41600.n53 a_21324_41600.t178 109.174
R3933 a_21324_41600.n54 a_21324_41600.t177 109.174
R3934 a_21324_41600.n55 a_21324_41600.t176 109.174
R3935 a_21324_41600.n56 a_21324_41600.t175 109.174
R3936 a_21324_41600.n57 a_21324_41600.t174 109.174
R3937 a_21324_41600.n58 a_21324_41600.t173 109.174
R3938 a_21324_41600.n59 a_21324_41600.t172 109.174
R3939 a_21324_41600.n60 a_21324_41600.t171 109.174
R3940 a_21324_41600.n61 a_21324_41600.t170 109.174
R3941 a_21324_41600.n62 a_21324_41600.t169 109.174
R3942 a_21324_41600.n63 a_21324_41600.t168 109.174
R3943 a_21324_41600.n64 a_21324_41600.t167 109.174
R3944 a_21324_41600.n65 a_21324_41600.t166 109.174
R3945 a_21324_41600.n66 a_21324_41600.t165 109.174
R3946 a_21324_41600.n67 a_21324_41600.t164 109.174
R3947 a_21324_41600.n68 a_21324_41600.t163 109.174
R3948 a_21324_41600.n69 a_21324_41600.t162 109.174
R3949 a_21324_41600.n70 a_21324_41600.t161 109.174
R3950 a_21324_41600.n130 a_21324_41600.t158 109.174
R3951 a_21324_41600.n71 a_21324_41600.t157 109.174
R3952 a_21324_41600.n126 a_21324_41600.t156 109.174
R3953 a_21324_41600.n125 a_21324_41600.t155 109.174
R3954 a_21324_41600.n124 a_21324_41600.t154 109.174
R3955 a_21324_41600.n73 a_21324_41600.t153 109.174
R3956 a_21324_41600.n120 a_21324_41600.t152 109.174
R3957 a_21324_41600.n119 a_21324_41600.t151 109.174
R3958 a_21324_41600.n118 a_21324_41600.t150 109.174
R3959 a_21324_41600.n75 a_21324_41600.t149 109.174
R3960 a_21324_41600.n114 a_21324_41600.t148 109.174
R3961 a_21324_41600.n113 a_21324_41600.t147 109.174
R3962 a_21324_41600.n112 a_21324_41600.t146 109.174
R3963 a_21324_41600.n77 a_21324_41600.t145 109.174
R3964 a_21324_41600.n108 a_21324_41600.t144 109.174
R3965 a_21324_41600.n107 a_21324_41600.t143 109.174
R3966 a_21324_41600.n106 a_21324_41600.t142 109.174
R3967 a_21324_41600.n79 a_21324_41600.t141 109.174
R3968 a_21324_41600.n102 a_21324_41600.t140 109.174
R3969 a_21324_41600.n101 a_21324_41600.t139 109.174
R3970 a_21324_41600.n100 a_21324_41600.t138 109.174
R3971 a_21324_41600.n81 a_21324_41600.t137 109.174
R3972 a_21324_41600.n96 a_21324_41600.t136 109.174
R3973 a_21324_41600.n95 a_21324_41600.t135 109.174
R3974 a_21324_41600.n94 a_21324_41600.t134 109.174
R3975 a_21324_41600.n83 a_21324_41600.t133 109.174
R3976 a_21324_41600.n90 a_21324_41600.t132 109.174
R3977 a_21324_41600.n89 a_21324_41600.t131 109.174
R3978 a_21324_41600.n88 a_21324_41600.t130 109.174
R3979 a_21324_41600.n85 a_21324_41600.t129 109.174
R3980 a_21324_41600.n292 a_21324_41600.n260 21.3114
R3981 a_21324_41600.n256 a_21324_41600.n135 18.4942
R3982 a_21324_41600.n258 a_21324_41600.n257 18.4942
R3983 a_21324_41600.n167 a_21324_41600.n164 18.4942
R3984 a_21324_41600.n168 a_21324_41600.n163 18.4942
R3985 a_21324_41600.n169 a_21324_41600.n162 18.4942
R3986 a_21324_41600.n170 a_21324_41600.n161 18.4942
R3987 a_21324_41600.n171 a_21324_41600.n160 18.4942
R3988 a_21324_41600.n172 a_21324_41600.n159 18.4942
R3989 a_21324_41600.n173 a_21324_41600.n158 18.4942
R3990 a_21324_41600.n174 a_21324_41600.n157 18.4942
R3991 a_21324_41600.n175 a_21324_41600.n156 18.4942
R3992 a_21324_41600.n176 a_21324_41600.n155 18.4942
R3993 a_21324_41600.n177 a_21324_41600.n154 18.4942
R3994 a_21324_41600.n178 a_21324_41600.n153 18.4942
R3995 a_21324_41600.n179 a_21324_41600.n152 18.4942
R3996 a_21324_41600.n180 a_21324_41600.n151 18.4942
R3997 a_21324_41600.n181 a_21324_41600.n150 18.4942
R3998 a_21324_41600.n182 a_21324_41600.n149 18.4942
R3999 a_21324_41600.n183 a_21324_41600.n148 18.4942
R4000 a_21324_41600.n184 a_21324_41600.n147 18.4942
R4001 a_21324_41600.n185 a_21324_41600.n146 18.4942
R4002 a_21324_41600.n186 a_21324_41600.n145 18.4942
R4003 a_21324_41600.n187 a_21324_41600.n144 18.4942
R4004 a_21324_41600.n188 a_21324_41600.n143 18.4942
R4005 a_21324_41600.n189 a_21324_41600.n142 18.4942
R4006 a_21324_41600.n190 a_21324_41600.n141 18.4942
R4007 a_21324_41600.n191 a_21324_41600.n140 18.4942
R4008 a_21324_41600.n192 a_21324_41600.n139 18.4942
R4009 a_21324_41600.n193 a_21324_41600.n138 18.4942
R4010 a_21324_41600.n194 a_21324_41600.n137 18.4942
R4011 a_21324_41600.n195 a_21324_41600.n136 18.4942
R4012 a_21324_41600.n255 a_21324_41600.n254 18.4942
R4013 a_21324_41600.n253 a_21324_41600.n196 18.4942
R4014 a_21324_41600.n252 a_21324_41600.n251 18.4942
R4015 a_21324_41600.n250 a_21324_41600.n197 18.4942
R4016 a_21324_41600.n249 a_21324_41600.n248 18.4942
R4017 a_21324_41600.n247 a_21324_41600.n198 18.4942
R4018 a_21324_41600.n246 a_21324_41600.n245 18.4942
R4019 a_21324_41600.n244 a_21324_41600.n199 18.4942
R4020 a_21324_41600.n243 a_21324_41600.n242 18.4942
R4021 a_21324_41600.n241 a_21324_41600.n200 18.4942
R4022 a_21324_41600.n240 a_21324_41600.n239 18.4942
R4023 a_21324_41600.n238 a_21324_41600.n201 18.4942
R4024 a_21324_41600.n237 a_21324_41600.n236 18.4942
R4025 a_21324_41600.n235 a_21324_41600.n202 18.4942
R4026 a_21324_41600.n234 a_21324_41600.n233 18.4942
R4027 a_21324_41600.n232 a_21324_41600.n203 18.4942
R4028 a_21324_41600.n231 a_21324_41600.n230 18.4942
R4029 a_21324_41600.n229 a_21324_41600.n204 18.4942
R4030 a_21324_41600.n228 a_21324_41600.n227 18.4942
R4031 a_21324_41600.n226 a_21324_41600.n205 18.4942
R4032 a_21324_41600.n225 a_21324_41600.n224 18.4942
R4033 a_21324_41600.n223 a_21324_41600.n206 18.4942
R4034 a_21324_41600.n222 a_21324_41600.n221 18.4942
R4035 a_21324_41600.n220 a_21324_41600.n207 18.4942
R4036 a_21324_41600.n219 a_21324_41600.n218 18.4942
R4037 a_21324_41600.n217 a_21324_41600.n208 18.4942
R4038 a_21324_41600.n216 a_21324_41600.n215 18.4942
R4039 a_21324_41600.n214 a_21324_41600.n209 18.4942
R4040 a_21324_41600.n213 a_21324_41600.n212 18.4942
R4041 a_21324_41600.n131 a_21324_41600.n10 18.4942
R4042 a_21324_41600.n133 a_21324_41600.n132 18.4942
R4043 a_21324_41600.n42 a_21324_41600.n39 18.4942
R4044 a_21324_41600.n43 a_21324_41600.n38 18.4942
R4045 a_21324_41600.n44 a_21324_41600.n37 18.4942
R4046 a_21324_41600.n45 a_21324_41600.n36 18.4942
R4047 a_21324_41600.n46 a_21324_41600.n35 18.4942
R4048 a_21324_41600.n47 a_21324_41600.n34 18.4942
R4049 a_21324_41600.n48 a_21324_41600.n33 18.4942
R4050 a_21324_41600.n49 a_21324_41600.n32 18.4942
R4051 a_21324_41600.n50 a_21324_41600.n31 18.4942
R4052 a_21324_41600.n51 a_21324_41600.n30 18.4942
R4053 a_21324_41600.n52 a_21324_41600.n29 18.4942
R4054 a_21324_41600.n53 a_21324_41600.n28 18.4942
R4055 a_21324_41600.n54 a_21324_41600.n27 18.4942
R4056 a_21324_41600.n55 a_21324_41600.n26 18.4942
R4057 a_21324_41600.n56 a_21324_41600.n25 18.4942
R4058 a_21324_41600.n57 a_21324_41600.n24 18.4942
R4059 a_21324_41600.n58 a_21324_41600.n23 18.4942
R4060 a_21324_41600.n59 a_21324_41600.n22 18.4942
R4061 a_21324_41600.n60 a_21324_41600.n21 18.4942
R4062 a_21324_41600.n61 a_21324_41600.n20 18.4942
R4063 a_21324_41600.n62 a_21324_41600.n19 18.4942
R4064 a_21324_41600.n63 a_21324_41600.n18 18.4942
R4065 a_21324_41600.n64 a_21324_41600.n17 18.4942
R4066 a_21324_41600.n65 a_21324_41600.n16 18.4942
R4067 a_21324_41600.n66 a_21324_41600.n15 18.4942
R4068 a_21324_41600.n67 a_21324_41600.n14 18.4942
R4069 a_21324_41600.n68 a_21324_41600.n13 18.4942
R4070 a_21324_41600.n69 a_21324_41600.n12 18.4942
R4071 a_21324_41600.n70 a_21324_41600.n11 18.4942
R4072 a_21324_41600.n130 a_21324_41600.n129 18.4942
R4073 a_21324_41600.n128 a_21324_41600.n71 18.4942
R4074 a_21324_41600.n127 a_21324_41600.n126 18.4942
R4075 a_21324_41600.n125 a_21324_41600.n72 18.4942
R4076 a_21324_41600.n124 a_21324_41600.n123 18.4942
R4077 a_21324_41600.n122 a_21324_41600.n73 18.4942
R4078 a_21324_41600.n121 a_21324_41600.n120 18.4942
R4079 a_21324_41600.n119 a_21324_41600.n74 18.4942
R4080 a_21324_41600.n118 a_21324_41600.n117 18.4942
R4081 a_21324_41600.n116 a_21324_41600.n75 18.4942
R4082 a_21324_41600.n115 a_21324_41600.n114 18.4942
R4083 a_21324_41600.n113 a_21324_41600.n76 18.4942
R4084 a_21324_41600.n112 a_21324_41600.n111 18.4942
R4085 a_21324_41600.n110 a_21324_41600.n77 18.4942
R4086 a_21324_41600.n109 a_21324_41600.n108 18.4942
R4087 a_21324_41600.n107 a_21324_41600.n78 18.4942
R4088 a_21324_41600.n106 a_21324_41600.n105 18.4942
R4089 a_21324_41600.n104 a_21324_41600.n79 18.4942
R4090 a_21324_41600.n103 a_21324_41600.n102 18.4942
R4091 a_21324_41600.n101 a_21324_41600.n80 18.4942
R4092 a_21324_41600.n100 a_21324_41600.n99 18.4942
R4093 a_21324_41600.n98 a_21324_41600.n81 18.4942
R4094 a_21324_41600.n97 a_21324_41600.n96 18.4942
R4095 a_21324_41600.n95 a_21324_41600.n82 18.4942
R4096 a_21324_41600.n94 a_21324_41600.n93 18.4942
R4097 a_21324_41600.n92 a_21324_41600.n83 18.4942
R4098 a_21324_41600.n91 a_21324_41600.n90 18.4942
R4099 a_21324_41600.n89 a_21324_41600.n84 18.4942
R4100 a_21324_41600.n88 a_21324_41600.n87 18.4942
R4101 a_21324_41600.n256 a_21324_41600.n255 11.6805
R4102 a_21324_41600.n257 a_21324_41600.n256 11.6805
R4103 a_21324_41600.n167 a_21324_41600.n166 11.6805
R4104 a_21324_41600.n168 a_21324_41600.n167 11.6805
R4105 a_21324_41600.n169 a_21324_41600.n168 11.6805
R4106 a_21324_41600.n170 a_21324_41600.n169 11.6805
R4107 a_21324_41600.n171 a_21324_41600.n170 11.6805
R4108 a_21324_41600.n172 a_21324_41600.n171 11.6805
R4109 a_21324_41600.n173 a_21324_41600.n172 11.6805
R4110 a_21324_41600.n174 a_21324_41600.n173 11.6805
R4111 a_21324_41600.n175 a_21324_41600.n174 11.6805
R4112 a_21324_41600.n176 a_21324_41600.n175 11.6805
R4113 a_21324_41600.n177 a_21324_41600.n176 11.6805
R4114 a_21324_41600.n178 a_21324_41600.n177 11.6805
R4115 a_21324_41600.n179 a_21324_41600.n178 11.6805
R4116 a_21324_41600.n180 a_21324_41600.n179 11.6805
R4117 a_21324_41600.n181 a_21324_41600.n180 11.6805
R4118 a_21324_41600.n182 a_21324_41600.n181 11.6805
R4119 a_21324_41600.n183 a_21324_41600.n182 11.6805
R4120 a_21324_41600.n184 a_21324_41600.n183 11.6805
R4121 a_21324_41600.n185 a_21324_41600.n184 11.6805
R4122 a_21324_41600.n186 a_21324_41600.n185 11.6805
R4123 a_21324_41600.n187 a_21324_41600.n186 11.6805
R4124 a_21324_41600.n188 a_21324_41600.n187 11.6805
R4125 a_21324_41600.n189 a_21324_41600.n188 11.6805
R4126 a_21324_41600.n190 a_21324_41600.n189 11.6805
R4127 a_21324_41600.n191 a_21324_41600.n190 11.6805
R4128 a_21324_41600.n192 a_21324_41600.n191 11.6805
R4129 a_21324_41600.n193 a_21324_41600.n192 11.6805
R4130 a_21324_41600.n194 a_21324_41600.n193 11.6805
R4131 a_21324_41600.n195 a_21324_41600.n194 11.6805
R4132 a_21324_41600.n257 a_21324_41600.n195 11.6805
R4133 a_21324_41600.n255 a_21324_41600.n196 11.6805
R4134 a_21324_41600.n251 a_21324_41600.n196 11.6805
R4135 a_21324_41600.n251 a_21324_41600.n250 11.6805
R4136 a_21324_41600.n250 a_21324_41600.n249 11.6805
R4137 a_21324_41600.n249 a_21324_41600.n198 11.6805
R4138 a_21324_41600.n245 a_21324_41600.n198 11.6805
R4139 a_21324_41600.n245 a_21324_41600.n244 11.6805
R4140 a_21324_41600.n244 a_21324_41600.n243 11.6805
R4141 a_21324_41600.n243 a_21324_41600.n200 11.6805
R4142 a_21324_41600.n239 a_21324_41600.n200 11.6805
R4143 a_21324_41600.n239 a_21324_41600.n238 11.6805
R4144 a_21324_41600.n238 a_21324_41600.n237 11.6805
R4145 a_21324_41600.n237 a_21324_41600.n202 11.6805
R4146 a_21324_41600.n233 a_21324_41600.n202 11.6805
R4147 a_21324_41600.n233 a_21324_41600.n232 11.6805
R4148 a_21324_41600.n232 a_21324_41600.n231 11.6805
R4149 a_21324_41600.n231 a_21324_41600.n204 11.6805
R4150 a_21324_41600.n227 a_21324_41600.n204 11.6805
R4151 a_21324_41600.n227 a_21324_41600.n226 11.6805
R4152 a_21324_41600.n226 a_21324_41600.n225 11.6805
R4153 a_21324_41600.n225 a_21324_41600.n206 11.6805
R4154 a_21324_41600.n221 a_21324_41600.n206 11.6805
R4155 a_21324_41600.n221 a_21324_41600.n220 11.6805
R4156 a_21324_41600.n220 a_21324_41600.n219 11.6805
R4157 a_21324_41600.n219 a_21324_41600.n208 11.6805
R4158 a_21324_41600.n215 a_21324_41600.n208 11.6805
R4159 a_21324_41600.n215 a_21324_41600.n214 11.6805
R4160 a_21324_41600.n214 a_21324_41600.n213 11.6805
R4161 a_21324_41600.n213 a_21324_41600.n210 11.6805
R4162 a_21324_41600.n131 a_21324_41600.n130 11.6805
R4163 a_21324_41600.n132 a_21324_41600.n131 11.6805
R4164 a_21324_41600.n42 a_21324_41600.n41 11.6805
R4165 a_21324_41600.n43 a_21324_41600.n42 11.6805
R4166 a_21324_41600.n44 a_21324_41600.n43 11.6805
R4167 a_21324_41600.n45 a_21324_41600.n44 11.6805
R4168 a_21324_41600.n46 a_21324_41600.n45 11.6805
R4169 a_21324_41600.n47 a_21324_41600.n46 11.6805
R4170 a_21324_41600.n48 a_21324_41600.n47 11.6805
R4171 a_21324_41600.n49 a_21324_41600.n48 11.6805
R4172 a_21324_41600.n50 a_21324_41600.n49 11.6805
R4173 a_21324_41600.n51 a_21324_41600.n50 11.6805
R4174 a_21324_41600.n52 a_21324_41600.n51 11.6805
R4175 a_21324_41600.n53 a_21324_41600.n52 11.6805
R4176 a_21324_41600.n54 a_21324_41600.n53 11.6805
R4177 a_21324_41600.n55 a_21324_41600.n54 11.6805
R4178 a_21324_41600.n56 a_21324_41600.n55 11.6805
R4179 a_21324_41600.n57 a_21324_41600.n56 11.6805
R4180 a_21324_41600.n58 a_21324_41600.n57 11.6805
R4181 a_21324_41600.n59 a_21324_41600.n58 11.6805
R4182 a_21324_41600.n60 a_21324_41600.n59 11.6805
R4183 a_21324_41600.n61 a_21324_41600.n60 11.6805
R4184 a_21324_41600.n62 a_21324_41600.n61 11.6805
R4185 a_21324_41600.n63 a_21324_41600.n62 11.6805
R4186 a_21324_41600.n64 a_21324_41600.n63 11.6805
R4187 a_21324_41600.n65 a_21324_41600.n64 11.6805
R4188 a_21324_41600.n66 a_21324_41600.n65 11.6805
R4189 a_21324_41600.n67 a_21324_41600.n66 11.6805
R4190 a_21324_41600.n68 a_21324_41600.n67 11.6805
R4191 a_21324_41600.n69 a_21324_41600.n68 11.6805
R4192 a_21324_41600.n70 a_21324_41600.n69 11.6805
R4193 a_21324_41600.n132 a_21324_41600.n70 11.6805
R4194 a_21324_41600.n130 a_21324_41600.n71 11.6805
R4195 a_21324_41600.n126 a_21324_41600.n71 11.6805
R4196 a_21324_41600.n126 a_21324_41600.n125 11.6805
R4197 a_21324_41600.n125 a_21324_41600.n124 11.6805
R4198 a_21324_41600.n124 a_21324_41600.n73 11.6805
R4199 a_21324_41600.n120 a_21324_41600.n73 11.6805
R4200 a_21324_41600.n120 a_21324_41600.n119 11.6805
R4201 a_21324_41600.n119 a_21324_41600.n118 11.6805
R4202 a_21324_41600.n118 a_21324_41600.n75 11.6805
R4203 a_21324_41600.n114 a_21324_41600.n75 11.6805
R4204 a_21324_41600.n114 a_21324_41600.n113 11.6805
R4205 a_21324_41600.n113 a_21324_41600.n112 11.6805
R4206 a_21324_41600.n112 a_21324_41600.n77 11.6805
R4207 a_21324_41600.n108 a_21324_41600.n77 11.6805
R4208 a_21324_41600.n108 a_21324_41600.n107 11.6805
R4209 a_21324_41600.n107 a_21324_41600.n106 11.6805
R4210 a_21324_41600.n106 a_21324_41600.n79 11.6805
R4211 a_21324_41600.n102 a_21324_41600.n79 11.6805
R4212 a_21324_41600.n102 a_21324_41600.n101 11.6805
R4213 a_21324_41600.n101 a_21324_41600.n100 11.6805
R4214 a_21324_41600.n100 a_21324_41600.n81 11.6805
R4215 a_21324_41600.n96 a_21324_41600.n81 11.6805
R4216 a_21324_41600.n96 a_21324_41600.n95 11.6805
R4217 a_21324_41600.n95 a_21324_41600.n94 11.6805
R4218 a_21324_41600.n94 a_21324_41600.n83 11.6805
R4219 a_21324_41600.n90 a_21324_41600.n83 11.6805
R4220 a_21324_41600.n90 a_21324_41600.n89 11.6805
R4221 a_21324_41600.n89 a_21324_41600.n88 11.6805
R4222 a_21324_41600.n88 a_21324_41600.n85 11.6805
R4223 a_21324_41600.n260 a_21324_41600.n134 10.3505
R4224 a_21324_41600.n260 a_21324_41600.n259 9.57907
R4225 a_21324_41600.n212 a_21324_41600.n211 7.17687
R4226 a_21324_41600.n165 a_21324_41600.n164 7.17687
R4227 a_21324_41600.n87 a_21324_41600.n86 7.17687
R4228 a_21324_41600.n40 a_21324_41600.n39 7.17687
R4229 a_21324_41600.n293 a_21324_41600.n292 6.5392
R4230 a_21324_41600.n262 a_21324_41600.t59 5.7796
R4231 a_21324_41600.n1 a_21324_41600.t44 5.73764
R4232 a_21324_41600.n291 a_21324_41600.t27 5.59012
R4233 a_21324_41600.n293 a_21324_41600.t54 5.54817
R4234 a_21324_41600.n262 a_21324_41600.n261 5.38537
R4235 a_21324_41600.n264 a_21324_41600.n263 5.38537
R4236 a_21324_41600.n266 a_21324_41600.n265 5.38537
R4237 a_21324_41600.n268 a_21324_41600.n267 5.38537
R4238 a_21324_41600.n270 a_21324_41600.n269 5.38537
R4239 a_21324_41600.n272 a_21324_41600.n271 5.38537
R4240 a_21324_41600.n274 a_21324_41600.n273 5.38537
R4241 a_21324_41600.n276 a_21324_41600.n275 5.38537
R4242 a_21324_41600.n278 a_21324_41600.n277 5.38537
R4243 a_21324_41600.n280 a_21324_41600.n279 5.38537
R4244 a_21324_41600.n282 a_21324_41600.n281 5.38537
R4245 a_21324_41600.n284 a_21324_41600.n283 5.38537
R4246 a_21324_41600.n286 a_21324_41600.n285 5.38537
R4247 a_21324_41600.n288 a_21324_41600.n287 5.38537
R4248 a_21324_41600.n290 a_21324_41600.n289 5.38537
R4249 a_21324_41600.n313 a_21324_41600.n312 5.32067
R4250 a_21324_41600.n1 a_21324_41600.n0 5.32067
R4251 a_21324_41600.n3 a_21324_41600.n2 5.32067
R4252 a_21324_41600.n5 a_21324_41600.n4 5.32067
R4253 a_21324_41600.n7 a_21324_41600.n6 5.32067
R4254 a_21324_41600.n9 a_21324_41600.n8 5.32067
R4255 a_21324_41600.n311 a_21324_41600.n310 5.32067
R4256 a_21324_41600.n309 a_21324_41600.n308 5.32067
R4257 a_21324_41600.n307 a_21324_41600.n306 5.32067
R4258 a_21324_41600.n305 a_21324_41600.n304 5.32067
R4259 a_21324_41600.n303 a_21324_41600.n302 5.32067
R4260 a_21324_41600.n301 a_21324_41600.n300 5.32067
R4261 a_21324_41600.n299 a_21324_41600.n298 5.32067
R4262 a_21324_41600.n297 a_21324_41600.n296 5.32067
R4263 a_21324_41600.n295 a_21324_41600.n294 5.32067
R4264 a_21324_41600.n292 a_21324_41600.n291 4.61063
R4265 a_21324_41600.n166 a_21324_41600.n165 4.42851
R4266 a_21324_41600.n211 a_21324_41600.n210 4.42851
R4267 a_21324_41600.n41 a_21324_41600.n40 4.42851
R4268 a_21324_41600.n86 a_21324_41600.n85 4.42851
R4269 a_21324_41600.t0 a_21324_41600.n313 0.228
R4270 a_21324_41600.n313 a_21324_41600.t42 0.228
R4271 a_21324_41600.n0 a_21324_41600.t43 0.228
R4272 a_21324_41600.n0 a_21324_41600.t30 0.228
R4273 a_21324_41600.n2 a_21324_41600.t12 0.228
R4274 a_21324_41600.n2 a_21324_41600.t17 0.228
R4275 a_21324_41600.n4 a_21324_41600.t39 0.228
R4276 a_21324_41600.n4 a_21324_41600.t48 0.228
R4277 a_21324_41600.n6 a_21324_41600.t9 0.228
R4278 a_21324_41600.n6 a_21324_41600.t61 0.228
R4279 a_21324_41600.n8 a_21324_41600.t36 0.228
R4280 a_21324_41600.n8 a_21324_41600.t53 0.228
R4281 a_21324_41600.n310 a_21324_41600.t38 0.228
R4282 a_21324_41600.n310 a_21324_41600.t15 0.228
R4283 a_21324_41600.n308 a_21324_41600.t32 0.228
R4284 a_21324_41600.n308 a_21324_41600.t20 0.228
R4285 a_21324_41600.n306 a_21324_41600.t51 0.228
R4286 a_21324_41600.n306 a_21324_41600.t31 0.228
R4287 a_21324_41600.n304 a_21324_41600.t52 0.228
R4288 a_21324_41600.n304 a_21324_41600.t18 0.228
R4289 a_21324_41600.n302 a_21324_41600.t7 0.228
R4290 a_21324_41600.n302 a_21324_41600.t21 0.228
R4291 a_21324_41600.n300 a_21324_41600.t19 0.228
R4292 a_21324_41600.n300 a_21324_41600.t22 0.228
R4293 a_21324_41600.n298 a_21324_41600.t2 0.228
R4294 a_21324_41600.n298 a_21324_41600.t60 0.228
R4295 a_21324_41600.n296 a_21324_41600.t6 0.228
R4296 a_21324_41600.n296 a_21324_41600.t1 0.228
R4297 a_21324_41600.n294 a_21324_41600.t16 0.228
R4298 a_21324_41600.n294 a_21324_41600.t8 0.228
R4299 a_21324_41600.n261 a_21324_41600.t56 0.20525
R4300 a_21324_41600.n261 a_21324_41600.t55 0.20525
R4301 a_21324_41600.n263 a_21324_41600.t50 0.20525
R4302 a_21324_41600.n263 a_21324_41600.t49 0.20525
R4303 a_21324_41600.n265 a_21324_41600.t63 0.20525
R4304 a_21324_41600.n265 a_21324_41600.t62 0.20525
R4305 a_21324_41600.n267 a_21324_41600.t11 0.20525
R4306 a_21324_41600.n267 a_21324_41600.t10 0.20525
R4307 a_21324_41600.n269 a_21324_41600.t5 0.20525
R4308 a_21324_41600.n269 a_21324_41600.t4 0.20525
R4309 a_21324_41600.n271 a_21324_41600.t41 0.20525
R4310 a_21324_41600.n271 a_21324_41600.t40 0.20525
R4311 a_21324_41600.n273 a_21324_41600.t14 0.20525
R4312 a_21324_41600.n273 a_21324_41600.t13 0.20525
R4313 a_21324_41600.n275 a_21324_41600.t24 0.20525
R4314 a_21324_41600.n275 a_21324_41600.t23 0.20525
R4315 a_21324_41600.n277 a_21324_41600.t46 0.20525
R4316 a_21324_41600.n277 a_21324_41600.t45 0.20525
R4317 a_21324_41600.n279 a_21324_41600.t34 0.20525
R4318 a_21324_41600.n279 a_21324_41600.t33 0.20525
R4319 a_21324_41600.n281 a_21324_41600.t29 0.20525
R4320 a_21324_41600.n281 a_21324_41600.t28 0.20525
R4321 a_21324_41600.n283 a_21324_41600.t3 0.20525
R4322 a_21324_41600.n283 a_21324_41600.t26 0.20525
R4323 a_21324_41600.n285 a_21324_41600.t25 0.20525
R4324 a_21324_41600.n285 a_21324_41600.t58 0.20525
R4325 a_21324_41600.n287 a_21324_41600.t57 0.20525
R4326 a_21324_41600.n287 a_21324_41600.t47 0.20525
R4327 a_21324_41600.n289 a_21324_41600.t35 0.20525
R4328 a_21324_41600.n289 a_21324_41600.t37 0.20525
R4329 a_21324_41600.n295 a_21324_41600.n293 0.189974
R4330 a_21324_41600.n297 a_21324_41600.n295 0.189974
R4331 a_21324_41600.n299 a_21324_41600.n297 0.189974
R4332 a_21324_41600.n301 a_21324_41600.n299 0.189974
R4333 a_21324_41600.n303 a_21324_41600.n301 0.189974
R4334 a_21324_41600.n305 a_21324_41600.n303 0.189974
R4335 a_21324_41600.n307 a_21324_41600.n305 0.189974
R4336 a_21324_41600.n309 a_21324_41600.n307 0.189974
R4337 a_21324_41600.n311 a_21324_41600.n309 0.189974
R4338 a_21324_41600.n312 a_21324_41600.n311 0.189974
R4339 a_21324_41600.n312 a_21324_41600.n9 0.189974
R4340 a_21324_41600.n9 a_21324_41600.n7 0.189974
R4341 a_21324_41600.n7 a_21324_41600.n5 0.189974
R4342 a_21324_41600.n5 a_21324_41600.n3 0.189974
R4343 a_21324_41600.n3 a_21324_41600.n1 0.189974
R4344 a_21324_41600.n291 a_21324_41600.n290 0.189974
R4345 a_21324_41600.n290 a_21324_41600.n288 0.189974
R4346 a_21324_41600.n288 a_21324_41600.n286 0.189974
R4347 a_21324_41600.n286 a_21324_41600.n284 0.189974
R4348 a_21324_41600.n284 a_21324_41600.n282 0.189974
R4349 a_21324_41600.n282 a_21324_41600.n280 0.189974
R4350 a_21324_41600.n280 a_21324_41600.n278 0.189974
R4351 a_21324_41600.n278 a_21324_41600.n276 0.189974
R4352 a_21324_41600.n276 a_21324_41600.n274 0.189974
R4353 a_21324_41600.n274 a_21324_41600.n272 0.189974
R4354 a_21324_41600.n272 a_21324_41600.n270 0.189974
R4355 a_21324_41600.n270 a_21324_41600.n268 0.189974
R4356 a_21324_41600.n268 a_21324_41600.n266 0.189974
R4357 a_21324_41600.n266 a_21324_41600.n264 0.189974
R4358 a_21324_41600.n264 a_21324_41600.n262 0.189974
R4359 a_21324_41600.n254 a_21324_41600.n135 0.1205
R4360 a_21324_41600.n254 a_21324_41600.n253 0.1205
R4361 a_21324_41600.n253 a_21324_41600.n252 0.1205
R4362 a_21324_41600.n252 a_21324_41600.n197 0.1205
R4363 a_21324_41600.n248 a_21324_41600.n197 0.1205
R4364 a_21324_41600.n248 a_21324_41600.n247 0.1205
R4365 a_21324_41600.n247 a_21324_41600.n246 0.1205
R4366 a_21324_41600.n246 a_21324_41600.n199 0.1205
R4367 a_21324_41600.n242 a_21324_41600.n199 0.1205
R4368 a_21324_41600.n242 a_21324_41600.n241 0.1205
R4369 a_21324_41600.n241 a_21324_41600.n240 0.1205
R4370 a_21324_41600.n240 a_21324_41600.n201 0.1205
R4371 a_21324_41600.n236 a_21324_41600.n201 0.1205
R4372 a_21324_41600.n236 a_21324_41600.n235 0.1205
R4373 a_21324_41600.n235 a_21324_41600.n234 0.1205
R4374 a_21324_41600.n234 a_21324_41600.n203 0.1205
R4375 a_21324_41600.n230 a_21324_41600.n203 0.1205
R4376 a_21324_41600.n230 a_21324_41600.n229 0.1205
R4377 a_21324_41600.n229 a_21324_41600.n228 0.1205
R4378 a_21324_41600.n228 a_21324_41600.n205 0.1205
R4379 a_21324_41600.n224 a_21324_41600.n205 0.1205
R4380 a_21324_41600.n224 a_21324_41600.n223 0.1205
R4381 a_21324_41600.n223 a_21324_41600.n222 0.1205
R4382 a_21324_41600.n222 a_21324_41600.n207 0.1205
R4383 a_21324_41600.n218 a_21324_41600.n207 0.1205
R4384 a_21324_41600.n218 a_21324_41600.n217 0.1205
R4385 a_21324_41600.n217 a_21324_41600.n216 0.1205
R4386 a_21324_41600.n216 a_21324_41600.n209 0.1205
R4387 a_21324_41600.n212 a_21324_41600.n209 0.1205
R4388 a_21324_41600.n164 a_21324_41600.n163 0.1205
R4389 a_21324_41600.n163 a_21324_41600.n162 0.1205
R4390 a_21324_41600.n162 a_21324_41600.n161 0.1205
R4391 a_21324_41600.n161 a_21324_41600.n160 0.1205
R4392 a_21324_41600.n160 a_21324_41600.n159 0.1205
R4393 a_21324_41600.n159 a_21324_41600.n158 0.1205
R4394 a_21324_41600.n158 a_21324_41600.n157 0.1205
R4395 a_21324_41600.n157 a_21324_41600.n156 0.1205
R4396 a_21324_41600.n156 a_21324_41600.n155 0.1205
R4397 a_21324_41600.n155 a_21324_41600.n154 0.1205
R4398 a_21324_41600.n154 a_21324_41600.n153 0.1205
R4399 a_21324_41600.n153 a_21324_41600.n152 0.1205
R4400 a_21324_41600.n152 a_21324_41600.n151 0.1205
R4401 a_21324_41600.n151 a_21324_41600.n150 0.1205
R4402 a_21324_41600.n150 a_21324_41600.n149 0.1205
R4403 a_21324_41600.n149 a_21324_41600.n148 0.1205
R4404 a_21324_41600.n148 a_21324_41600.n147 0.1205
R4405 a_21324_41600.n147 a_21324_41600.n146 0.1205
R4406 a_21324_41600.n146 a_21324_41600.n145 0.1205
R4407 a_21324_41600.n145 a_21324_41600.n144 0.1205
R4408 a_21324_41600.n144 a_21324_41600.n143 0.1205
R4409 a_21324_41600.n143 a_21324_41600.n142 0.1205
R4410 a_21324_41600.n142 a_21324_41600.n141 0.1205
R4411 a_21324_41600.n141 a_21324_41600.n140 0.1205
R4412 a_21324_41600.n140 a_21324_41600.n139 0.1205
R4413 a_21324_41600.n139 a_21324_41600.n138 0.1205
R4414 a_21324_41600.n138 a_21324_41600.n137 0.1205
R4415 a_21324_41600.n137 a_21324_41600.n136 0.1205
R4416 a_21324_41600.n258 a_21324_41600.n136 0.1205
R4417 a_21324_41600.n129 a_21324_41600.n10 0.1205
R4418 a_21324_41600.n129 a_21324_41600.n128 0.1205
R4419 a_21324_41600.n128 a_21324_41600.n127 0.1205
R4420 a_21324_41600.n127 a_21324_41600.n72 0.1205
R4421 a_21324_41600.n123 a_21324_41600.n72 0.1205
R4422 a_21324_41600.n123 a_21324_41600.n122 0.1205
R4423 a_21324_41600.n122 a_21324_41600.n121 0.1205
R4424 a_21324_41600.n121 a_21324_41600.n74 0.1205
R4425 a_21324_41600.n117 a_21324_41600.n74 0.1205
R4426 a_21324_41600.n117 a_21324_41600.n116 0.1205
R4427 a_21324_41600.n116 a_21324_41600.n115 0.1205
R4428 a_21324_41600.n115 a_21324_41600.n76 0.1205
R4429 a_21324_41600.n111 a_21324_41600.n76 0.1205
R4430 a_21324_41600.n111 a_21324_41600.n110 0.1205
R4431 a_21324_41600.n110 a_21324_41600.n109 0.1205
R4432 a_21324_41600.n109 a_21324_41600.n78 0.1205
R4433 a_21324_41600.n105 a_21324_41600.n78 0.1205
R4434 a_21324_41600.n105 a_21324_41600.n104 0.1205
R4435 a_21324_41600.n104 a_21324_41600.n103 0.1205
R4436 a_21324_41600.n103 a_21324_41600.n80 0.1205
R4437 a_21324_41600.n99 a_21324_41600.n80 0.1205
R4438 a_21324_41600.n99 a_21324_41600.n98 0.1205
R4439 a_21324_41600.n98 a_21324_41600.n97 0.1205
R4440 a_21324_41600.n97 a_21324_41600.n82 0.1205
R4441 a_21324_41600.n93 a_21324_41600.n82 0.1205
R4442 a_21324_41600.n93 a_21324_41600.n92 0.1205
R4443 a_21324_41600.n92 a_21324_41600.n91 0.1205
R4444 a_21324_41600.n91 a_21324_41600.n84 0.1205
R4445 a_21324_41600.n87 a_21324_41600.n84 0.1205
R4446 a_21324_41600.n39 a_21324_41600.n38 0.1205
R4447 a_21324_41600.n38 a_21324_41600.n37 0.1205
R4448 a_21324_41600.n37 a_21324_41600.n36 0.1205
R4449 a_21324_41600.n36 a_21324_41600.n35 0.1205
R4450 a_21324_41600.n35 a_21324_41600.n34 0.1205
R4451 a_21324_41600.n34 a_21324_41600.n33 0.1205
R4452 a_21324_41600.n33 a_21324_41600.n32 0.1205
R4453 a_21324_41600.n32 a_21324_41600.n31 0.1205
R4454 a_21324_41600.n31 a_21324_41600.n30 0.1205
R4455 a_21324_41600.n30 a_21324_41600.n29 0.1205
R4456 a_21324_41600.n29 a_21324_41600.n28 0.1205
R4457 a_21324_41600.n28 a_21324_41600.n27 0.1205
R4458 a_21324_41600.n27 a_21324_41600.n26 0.1205
R4459 a_21324_41600.n26 a_21324_41600.n25 0.1205
R4460 a_21324_41600.n25 a_21324_41600.n24 0.1205
R4461 a_21324_41600.n24 a_21324_41600.n23 0.1205
R4462 a_21324_41600.n23 a_21324_41600.n22 0.1205
R4463 a_21324_41600.n22 a_21324_41600.n21 0.1205
R4464 a_21324_41600.n21 a_21324_41600.n20 0.1205
R4465 a_21324_41600.n20 a_21324_41600.n19 0.1205
R4466 a_21324_41600.n19 a_21324_41600.n18 0.1205
R4467 a_21324_41600.n18 a_21324_41600.n17 0.1205
R4468 a_21324_41600.n17 a_21324_41600.n16 0.1205
R4469 a_21324_41600.n16 a_21324_41600.n15 0.1205
R4470 a_21324_41600.n15 a_21324_41600.n14 0.1205
R4471 a_21324_41600.n14 a_21324_41600.n13 0.1205
R4472 a_21324_41600.n13 a_21324_41600.n12 0.1205
R4473 a_21324_41600.n12 a_21324_41600.n11 0.1205
R4474 a_21324_41600.n133 a_21324_41600.n11 0.1205
R4475 a_21324_41600.n259 a_21324_41600.n135 0.0485
R4476 a_21324_41600.n259 a_21324_41600.n258 0.0485
R4477 a_21324_41600.n134 a_21324_41600.n10 0.0485
R4478 a_21324_41600.n134 a_21324_41600.n133 0.0485
R4479 a_17292_41600.n83 a_17292_41600.t63 113.632
R4480 a_17292_41600.n105 a_17292_41600.t32 113.632
R4481 a_17292_41600.n22 a_17292_41600.t95 113.632
R4482 a_17292_41600.n44 a_17292_41600.t64 113.632
R4483 a_17292_41600.n126 a_17292_41600.t47 109.174
R4484 a_17292_41600.n127 a_17292_41600.t48 109.174
R4485 a_17292_41600.n84 a_17292_41600.t62 109.174
R4486 a_17292_41600.n85 a_17292_41600.t61 109.174
R4487 a_17292_41600.n86 a_17292_41600.t60 109.174
R4488 a_17292_41600.n87 a_17292_41600.t59 109.174
R4489 a_17292_41600.n88 a_17292_41600.t58 109.174
R4490 a_17292_41600.n89 a_17292_41600.t57 109.174
R4491 a_17292_41600.n90 a_17292_41600.t56 109.174
R4492 a_17292_41600.n91 a_17292_41600.t55 109.174
R4493 a_17292_41600.n92 a_17292_41600.t54 109.174
R4494 a_17292_41600.n93 a_17292_41600.t53 109.174
R4495 a_17292_41600.n94 a_17292_41600.t52 109.174
R4496 a_17292_41600.n95 a_17292_41600.t51 109.174
R4497 a_17292_41600.n96 a_17292_41600.t50 109.174
R4498 a_17292_41600.n97 a_17292_41600.t49 109.174
R4499 a_17292_41600.n125 a_17292_41600.t46 109.174
R4500 a_17292_41600.n98 a_17292_41600.t45 109.174
R4501 a_17292_41600.n121 a_17292_41600.t44 109.174
R4502 a_17292_41600.n120 a_17292_41600.t43 109.174
R4503 a_17292_41600.n119 a_17292_41600.t42 109.174
R4504 a_17292_41600.n100 a_17292_41600.t41 109.174
R4505 a_17292_41600.n115 a_17292_41600.t40 109.174
R4506 a_17292_41600.n114 a_17292_41600.t39 109.174
R4507 a_17292_41600.n113 a_17292_41600.t38 109.174
R4508 a_17292_41600.n102 a_17292_41600.t37 109.174
R4509 a_17292_41600.n109 a_17292_41600.t36 109.174
R4510 a_17292_41600.n108 a_17292_41600.t35 109.174
R4511 a_17292_41600.n107 a_17292_41600.t34 109.174
R4512 a_17292_41600.n104 a_17292_41600.t33 109.174
R4513 a_17292_41600.n65 a_17292_41600.t79 109.174
R4514 a_17292_41600.n66 a_17292_41600.t80 109.174
R4515 a_17292_41600.n23 a_17292_41600.t94 109.174
R4516 a_17292_41600.n24 a_17292_41600.t93 109.174
R4517 a_17292_41600.n25 a_17292_41600.t92 109.174
R4518 a_17292_41600.n26 a_17292_41600.t91 109.174
R4519 a_17292_41600.n27 a_17292_41600.t90 109.174
R4520 a_17292_41600.n28 a_17292_41600.t89 109.174
R4521 a_17292_41600.n29 a_17292_41600.t88 109.174
R4522 a_17292_41600.n30 a_17292_41600.t87 109.174
R4523 a_17292_41600.n31 a_17292_41600.t86 109.174
R4524 a_17292_41600.n32 a_17292_41600.t85 109.174
R4525 a_17292_41600.n33 a_17292_41600.t84 109.174
R4526 a_17292_41600.n34 a_17292_41600.t83 109.174
R4527 a_17292_41600.n35 a_17292_41600.t82 109.174
R4528 a_17292_41600.n36 a_17292_41600.t81 109.174
R4529 a_17292_41600.n64 a_17292_41600.t78 109.174
R4530 a_17292_41600.n37 a_17292_41600.t77 109.174
R4531 a_17292_41600.n60 a_17292_41600.t76 109.174
R4532 a_17292_41600.n59 a_17292_41600.t75 109.174
R4533 a_17292_41600.n58 a_17292_41600.t74 109.174
R4534 a_17292_41600.n39 a_17292_41600.t73 109.174
R4535 a_17292_41600.n54 a_17292_41600.t72 109.174
R4536 a_17292_41600.n53 a_17292_41600.t71 109.174
R4537 a_17292_41600.n52 a_17292_41600.t70 109.174
R4538 a_17292_41600.n41 a_17292_41600.t69 109.174
R4539 a_17292_41600.n48 a_17292_41600.t68 109.174
R4540 a_17292_41600.n47 a_17292_41600.t67 109.174
R4541 a_17292_41600.n46 a_17292_41600.t66 109.174
R4542 a_17292_41600.n43 a_17292_41600.t65 109.174
R4543 a_17292_41600.n126 a_17292_41600.n69 18.4942
R4544 a_17292_41600.n128 a_17292_41600.n127 18.4942
R4545 a_17292_41600.n85 a_17292_41600.n82 18.4942
R4546 a_17292_41600.n86 a_17292_41600.n81 18.4942
R4547 a_17292_41600.n87 a_17292_41600.n80 18.4942
R4548 a_17292_41600.n88 a_17292_41600.n79 18.4942
R4549 a_17292_41600.n89 a_17292_41600.n78 18.4942
R4550 a_17292_41600.n90 a_17292_41600.n77 18.4942
R4551 a_17292_41600.n91 a_17292_41600.n76 18.4942
R4552 a_17292_41600.n92 a_17292_41600.n75 18.4942
R4553 a_17292_41600.n93 a_17292_41600.n74 18.4942
R4554 a_17292_41600.n94 a_17292_41600.n73 18.4942
R4555 a_17292_41600.n95 a_17292_41600.n72 18.4942
R4556 a_17292_41600.n96 a_17292_41600.n71 18.4942
R4557 a_17292_41600.n97 a_17292_41600.n70 18.4942
R4558 a_17292_41600.n125 a_17292_41600.n124 18.4942
R4559 a_17292_41600.n123 a_17292_41600.n98 18.4942
R4560 a_17292_41600.n122 a_17292_41600.n121 18.4942
R4561 a_17292_41600.n120 a_17292_41600.n99 18.4942
R4562 a_17292_41600.n119 a_17292_41600.n118 18.4942
R4563 a_17292_41600.n117 a_17292_41600.n100 18.4942
R4564 a_17292_41600.n116 a_17292_41600.n115 18.4942
R4565 a_17292_41600.n114 a_17292_41600.n101 18.4942
R4566 a_17292_41600.n113 a_17292_41600.n112 18.4942
R4567 a_17292_41600.n111 a_17292_41600.n102 18.4942
R4568 a_17292_41600.n110 a_17292_41600.n109 18.4942
R4569 a_17292_41600.n108 a_17292_41600.n103 18.4942
R4570 a_17292_41600.n107 a_17292_41600.n106 18.4942
R4571 a_17292_41600.n65 a_17292_41600.n8 18.4942
R4572 a_17292_41600.n67 a_17292_41600.n66 18.4942
R4573 a_17292_41600.n24 a_17292_41600.n21 18.4942
R4574 a_17292_41600.n25 a_17292_41600.n20 18.4942
R4575 a_17292_41600.n26 a_17292_41600.n19 18.4942
R4576 a_17292_41600.n27 a_17292_41600.n18 18.4942
R4577 a_17292_41600.n28 a_17292_41600.n17 18.4942
R4578 a_17292_41600.n29 a_17292_41600.n16 18.4942
R4579 a_17292_41600.n30 a_17292_41600.n15 18.4942
R4580 a_17292_41600.n31 a_17292_41600.n14 18.4942
R4581 a_17292_41600.n32 a_17292_41600.n13 18.4942
R4582 a_17292_41600.n33 a_17292_41600.n12 18.4942
R4583 a_17292_41600.n34 a_17292_41600.n11 18.4942
R4584 a_17292_41600.n35 a_17292_41600.n10 18.4942
R4585 a_17292_41600.n36 a_17292_41600.n9 18.4942
R4586 a_17292_41600.n64 a_17292_41600.n63 18.4942
R4587 a_17292_41600.n62 a_17292_41600.n37 18.4942
R4588 a_17292_41600.n61 a_17292_41600.n60 18.4942
R4589 a_17292_41600.n59 a_17292_41600.n38 18.4942
R4590 a_17292_41600.n58 a_17292_41600.n57 18.4942
R4591 a_17292_41600.n56 a_17292_41600.n39 18.4942
R4592 a_17292_41600.n55 a_17292_41600.n54 18.4942
R4593 a_17292_41600.n53 a_17292_41600.n40 18.4942
R4594 a_17292_41600.n52 a_17292_41600.n51 18.4942
R4595 a_17292_41600.n50 a_17292_41600.n41 18.4942
R4596 a_17292_41600.n49 a_17292_41600.n48 18.4942
R4597 a_17292_41600.n47 a_17292_41600.n42 18.4942
R4598 a_17292_41600.n46 a_17292_41600.n45 18.4942
R4599 a_17292_41600.n146 a_17292_41600.n130 17.0741
R4600 a_17292_41600.n126 a_17292_41600.n125 11.6805
R4601 a_17292_41600.n127 a_17292_41600.n126 11.6805
R4602 a_17292_41600.n85 a_17292_41600.n84 11.6805
R4603 a_17292_41600.n86 a_17292_41600.n85 11.6805
R4604 a_17292_41600.n87 a_17292_41600.n86 11.6805
R4605 a_17292_41600.n88 a_17292_41600.n87 11.6805
R4606 a_17292_41600.n89 a_17292_41600.n88 11.6805
R4607 a_17292_41600.n90 a_17292_41600.n89 11.6805
R4608 a_17292_41600.n91 a_17292_41600.n90 11.6805
R4609 a_17292_41600.n92 a_17292_41600.n91 11.6805
R4610 a_17292_41600.n93 a_17292_41600.n92 11.6805
R4611 a_17292_41600.n94 a_17292_41600.n93 11.6805
R4612 a_17292_41600.n95 a_17292_41600.n94 11.6805
R4613 a_17292_41600.n96 a_17292_41600.n95 11.6805
R4614 a_17292_41600.n97 a_17292_41600.n96 11.6805
R4615 a_17292_41600.n127 a_17292_41600.n97 11.6805
R4616 a_17292_41600.n125 a_17292_41600.n98 11.6805
R4617 a_17292_41600.n121 a_17292_41600.n98 11.6805
R4618 a_17292_41600.n121 a_17292_41600.n120 11.6805
R4619 a_17292_41600.n120 a_17292_41600.n119 11.6805
R4620 a_17292_41600.n119 a_17292_41600.n100 11.6805
R4621 a_17292_41600.n115 a_17292_41600.n100 11.6805
R4622 a_17292_41600.n115 a_17292_41600.n114 11.6805
R4623 a_17292_41600.n114 a_17292_41600.n113 11.6805
R4624 a_17292_41600.n113 a_17292_41600.n102 11.6805
R4625 a_17292_41600.n109 a_17292_41600.n102 11.6805
R4626 a_17292_41600.n109 a_17292_41600.n108 11.6805
R4627 a_17292_41600.n108 a_17292_41600.n107 11.6805
R4628 a_17292_41600.n107 a_17292_41600.n104 11.6805
R4629 a_17292_41600.n65 a_17292_41600.n64 11.6805
R4630 a_17292_41600.n66 a_17292_41600.n65 11.6805
R4631 a_17292_41600.n24 a_17292_41600.n23 11.6805
R4632 a_17292_41600.n25 a_17292_41600.n24 11.6805
R4633 a_17292_41600.n26 a_17292_41600.n25 11.6805
R4634 a_17292_41600.n27 a_17292_41600.n26 11.6805
R4635 a_17292_41600.n28 a_17292_41600.n27 11.6805
R4636 a_17292_41600.n29 a_17292_41600.n28 11.6805
R4637 a_17292_41600.n30 a_17292_41600.n29 11.6805
R4638 a_17292_41600.n31 a_17292_41600.n30 11.6805
R4639 a_17292_41600.n32 a_17292_41600.n31 11.6805
R4640 a_17292_41600.n33 a_17292_41600.n32 11.6805
R4641 a_17292_41600.n34 a_17292_41600.n33 11.6805
R4642 a_17292_41600.n35 a_17292_41600.n34 11.6805
R4643 a_17292_41600.n36 a_17292_41600.n35 11.6805
R4644 a_17292_41600.n66 a_17292_41600.n36 11.6805
R4645 a_17292_41600.n64 a_17292_41600.n37 11.6805
R4646 a_17292_41600.n60 a_17292_41600.n37 11.6805
R4647 a_17292_41600.n60 a_17292_41600.n59 11.6805
R4648 a_17292_41600.n59 a_17292_41600.n58 11.6805
R4649 a_17292_41600.n58 a_17292_41600.n39 11.6805
R4650 a_17292_41600.n54 a_17292_41600.n39 11.6805
R4651 a_17292_41600.n54 a_17292_41600.n53 11.6805
R4652 a_17292_41600.n53 a_17292_41600.n52 11.6805
R4653 a_17292_41600.n52 a_17292_41600.n41 11.6805
R4654 a_17292_41600.n48 a_17292_41600.n41 11.6805
R4655 a_17292_41600.n48 a_17292_41600.n47 11.6805
R4656 a_17292_41600.n47 a_17292_41600.n46 11.6805
R4657 a_17292_41600.n46 a_17292_41600.n43 11.6805
R4658 a_17292_41600.n130 a_17292_41600.n68 10.9291
R4659 a_17292_41600.n130 a_17292_41600.n129 9.0005
R4660 a_17292_41600.n106 a_17292_41600.n105 7.17687
R4661 a_17292_41600.n83 a_17292_41600.n82 7.17687
R4662 a_17292_41600.n45 a_17292_41600.n44 7.17687
R4663 a_17292_41600.n22 a_17292_41600.n21 7.17687
R4664 a_17292_41600.n147 a_17292_41600.n146 6.5392
R4665 a_17292_41600.n132 a_17292_41600.t10 5.7796
R4666 a_17292_41600.n1 a_17292_41600.t8 5.73764
R4667 a_17292_41600.n145 a_17292_41600.t13 5.59012
R4668 a_17292_41600.n147 a_17292_41600.t31 5.54817
R4669 a_17292_41600.n132 a_17292_41600.n131 5.38537
R4670 a_17292_41600.n134 a_17292_41600.n133 5.38537
R4671 a_17292_41600.n136 a_17292_41600.n135 5.38537
R4672 a_17292_41600.n138 a_17292_41600.n137 5.38537
R4673 a_17292_41600.n140 a_17292_41600.n139 5.38537
R4674 a_17292_41600.n142 a_17292_41600.n141 5.38537
R4675 a_17292_41600.n144 a_17292_41600.n143 5.38537
R4676 a_17292_41600.n153 a_17292_41600.n152 5.32067
R4677 a_17292_41600.n1 a_17292_41600.n0 5.32067
R4678 a_17292_41600.n3 a_17292_41600.n2 5.32067
R4679 a_17292_41600.n5 a_17292_41600.n4 5.32067
R4680 a_17292_41600.n7 a_17292_41600.n6 5.32067
R4681 a_17292_41600.n151 a_17292_41600.n150 5.32067
R4682 a_17292_41600.n149 a_17292_41600.n148 5.32067
R4683 a_17292_41600.n146 a_17292_41600.n145 4.61063
R4684 a_17292_41600.n84 a_17292_41600.n83 4.42851
R4685 a_17292_41600.n105 a_17292_41600.n104 4.42851
R4686 a_17292_41600.n23 a_17292_41600.n22 4.42851
R4687 a_17292_41600.n44 a_17292_41600.n43 4.42851
R4688 a_17292_41600.t0 a_17292_41600.n153 0.228
R4689 a_17292_41600.n153 a_17292_41600.t7 0.228
R4690 a_17292_41600.n0 a_17292_41600.t22 0.228
R4691 a_17292_41600.n0 a_17292_41600.t9 0.228
R4692 a_17292_41600.n2 a_17292_41600.t2 0.228
R4693 a_17292_41600.n2 a_17292_41600.t23 0.228
R4694 a_17292_41600.n4 a_17292_41600.t4 0.228
R4695 a_17292_41600.n4 a_17292_41600.t3 0.228
R4696 a_17292_41600.n6 a_17292_41600.t6 0.228
R4697 a_17292_41600.n6 a_17292_41600.t5 0.228
R4698 a_17292_41600.n150 a_17292_41600.t20 0.228
R4699 a_17292_41600.n150 a_17292_41600.t1 0.228
R4700 a_17292_41600.n148 a_17292_41600.t30 0.228
R4701 a_17292_41600.n148 a_17292_41600.t21 0.228
R4702 a_17292_41600.n131 a_17292_41600.t24 0.20525
R4703 a_17292_41600.n131 a_17292_41600.t11 0.20525
R4704 a_17292_41600.n133 a_17292_41600.t26 0.20525
R4705 a_17292_41600.n133 a_17292_41600.t25 0.20525
R4706 a_17292_41600.n135 a_17292_41600.t28 0.20525
R4707 a_17292_41600.n135 a_17292_41600.t27 0.20525
R4708 a_17292_41600.n137 a_17292_41600.t18 0.20525
R4709 a_17292_41600.n137 a_17292_41600.t29 0.20525
R4710 a_17292_41600.n139 a_17292_41600.t14 0.20525
R4711 a_17292_41600.n139 a_17292_41600.t19 0.20525
R4712 a_17292_41600.n141 a_17292_41600.t16 0.20525
R4713 a_17292_41600.n141 a_17292_41600.t15 0.20525
R4714 a_17292_41600.n143 a_17292_41600.t12 0.20525
R4715 a_17292_41600.n143 a_17292_41600.t17 0.20525
R4716 a_17292_41600.n149 a_17292_41600.n147 0.189974
R4717 a_17292_41600.n151 a_17292_41600.n149 0.189974
R4718 a_17292_41600.n152 a_17292_41600.n151 0.189974
R4719 a_17292_41600.n152 a_17292_41600.n7 0.189974
R4720 a_17292_41600.n7 a_17292_41600.n5 0.189974
R4721 a_17292_41600.n5 a_17292_41600.n3 0.189974
R4722 a_17292_41600.n3 a_17292_41600.n1 0.189974
R4723 a_17292_41600.n145 a_17292_41600.n144 0.189974
R4724 a_17292_41600.n144 a_17292_41600.n142 0.189974
R4725 a_17292_41600.n142 a_17292_41600.n140 0.189974
R4726 a_17292_41600.n140 a_17292_41600.n138 0.189974
R4727 a_17292_41600.n138 a_17292_41600.n136 0.189974
R4728 a_17292_41600.n136 a_17292_41600.n134 0.189974
R4729 a_17292_41600.n134 a_17292_41600.n132 0.189974
R4730 a_17292_41600.n124 a_17292_41600.n69 0.1205
R4731 a_17292_41600.n124 a_17292_41600.n123 0.1205
R4732 a_17292_41600.n123 a_17292_41600.n122 0.1205
R4733 a_17292_41600.n122 a_17292_41600.n99 0.1205
R4734 a_17292_41600.n118 a_17292_41600.n99 0.1205
R4735 a_17292_41600.n118 a_17292_41600.n117 0.1205
R4736 a_17292_41600.n117 a_17292_41600.n116 0.1205
R4737 a_17292_41600.n116 a_17292_41600.n101 0.1205
R4738 a_17292_41600.n112 a_17292_41600.n101 0.1205
R4739 a_17292_41600.n112 a_17292_41600.n111 0.1205
R4740 a_17292_41600.n111 a_17292_41600.n110 0.1205
R4741 a_17292_41600.n110 a_17292_41600.n103 0.1205
R4742 a_17292_41600.n106 a_17292_41600.n103 0.1205
R4743 a_17292_41600.n82 a_17292_41600.n81 0.1205
R4744 a_17292_41600.n81 a_17292_41600.n80 0.1205
R4745 a_17292_41600.n80 a_17292_41600.n79 0.1205
R4746 a_17292_41600.n79 a_17292_41600.n78 0.1205
R4747 a_17292_41600.n78 a_17292_41600.n77 0.1205
R4748 a_17292_41600.n77 a_17292_41600.n76 0.1205
R4749 a_17292_41600.n76 a_17292_41600.n75 0.1205
R4750 a_17292_41600.n75 a_17292_41600.n74 0.1205
R4751 a_17292_41600.n74 a_17292_41600.n73 0.1205
R4752 a_17292_41600.n73 a_17292_41600.n72 0.1205
R4753 a_17292_41600.n72 a_17292_41600.n71 0.1205
R4754 a_17292_41600.n71 a_17292_41600.n70 0.1205
R4755 a_17292_41600.n128 a_17292_41600.n70 0.1205
R4756 a_17292_41600.n63 a_17292_41600.n8 0.1205
R4757 a_17292_41600.n63 a_17292_41600.n62 0.1205
R4758 a_17292_41600.n62 a_17292_41600.n61 0.1205
R4759 a_17292_41600.n61 a_17292_41600.n38 0.1205
R4760 a_17292_41600.n57 a_17292_41600.n38 0.1205
R4761 a_17292_41600.n57 a_17292_41600.n56 0.1205
R4762 a_17292_41600.n56 a_17292_41600.n55 0.1205
R4763 a_17292_41600.n55 a_17292_41600.n40 0.1205
R4764 a_17292_41600.n51 a_17292_41600.n40 0.1205
R4765 a_17292_41600.n51 a_17292_41600.n50 0.1205
R4766 a_17292_41600.n50 a_17292_41600.n49 0.1205
R4767 a_17292_41600.n49 a_17292_41600.n42 0.1205
R4768 a_17292_41600.n45 a_17292_41600.n42 0.1205
R4769 a_17292_41600.n21 a_17292_41600.n20 0.1205
R4770 a_17292_41600.n20 a_17292_41600.n19 0.1205
R4771 a_17292_41600.n19 a_17292_41600.n18 0.1205
R4772 a_17292_41600.n18 a_17292_41600.n17 0.1205
R4773 a_17292_41600.n17 a_17292_41600.n16 0.1205
R4774 a_17292_41600.n16 a_17292_41600.n15 0.1205
R4775 a_17292_41600.n15 a_17292_41600.n14 0.1205
R4776 a_17292_41600.n14 a_17292_41600.n13 0.1205
R4777 a_17292_41600.n13 a_17292_41600.n12 0.1205
R4778 a_17292_41600.n12 a_17292_41600.n11 0.1205
R4779 a_17292_41600.n11 a_17292_41600.n10 0.1205
R4780 a_17292_41600.n10 a_17292_41600.n9 0.1205
R4781 a_17292_41600.n67 a_17292_41600.n9 0.1205
R4782 a_17292_41600.n129 a_17292_41600.n69 0.0485
R4783 a_17292_41600.n129 a_17292_41600.n128 0.0485
R4784 a_17292_41600.n68 a_17292_41600.n8 0.0485
R4785 a_17292_41600.n68 a_17292_41600.n67 0.0485
R4786 a_14540_41600.n39 a_14540_41600.t31 113.632
R4787 a_14540_41600.n49 a_14540_41600.t16 113.632
R4788 a_14540_41600.n10 a_14540_41600.t47 113.632
R4789 a_14540_41600.n20 a_14540_41600.t32 113.632
R4790 a_14540_41600.n58 a_14540_41600.t23 109.174
R4791 a_14540_41600.n59 a_14540_41600.t24 109.174
R4792 a_14540_41600.n40 a_14540_41600.t30 109.174
R4793 a_14540_41600.n41 a_14540_41600.t29 109.174
R4794 a_14540_41600.n42 a_14540_41600.t28 109.174
R4795 a_14540_41600.n43 a_14540_41600.t27 109.174
R4796 a_14540_41600.n44 a_14540_41600.t26 109.174
R4797 a_14540_41600.n45 a_14540_41600.t25 109.174
R4798 a_14540_41600.n57 a_14540_41600.t22 109.174
R4799 a_14540_41600.n46 a_14540_41600.t21 109.174
R4800 a_14540_41600.n53 a_14540_41600.t20 109.174
R4801 a_14540_41600.n52 a_14540_41600.t19 109.174
R4802 a_14540_41600.n51 a_14540_41600.t18 109.174
R4803 a_14540_41600.n48 a_14540_41600.t17 109.174
R4804 a_14540_41600.n29 a_14540_41600.t39 109.174
R4805 a_14540_41600.n30 a_14540_41600.t40 109.174
R4806 a_14540_41600.n11 a_14540_41600.t46 109.174
R4807 a_14540_41600.n12 a_14540_41600.t45 109.174
R4808 a_14540_41600.n13 a_14540_41600.t44 109.174
R4809 a_14540_41600.n14 a_14540_41600.t43 109.174
R4810 a_14540_41600.n15 a_14540_41600.t42 109.174
R4811 a_14540_41600.n16 a_14540_41600.t41 109.174
R4812 a_14540_41600.n28 a_14540_41600.t38 109.174
R4813 a_14540_41600.n17 a_14540_41600.t37 109.174
R4814 a_14540_41600.n24 a_14540_41600.t36 109.174
R4815 a_14540_41600.n23 a_14540_41600.t35 109.174
R4816 a_14540_41600.n22 a_14540_41600.t34 109.174
R4817 a_14540_41600.n19 a_14540_41600.t33 109.174
R4818 a_14540_41600.n58 a_14540_41600.n33 18.4942
R4819 a_14540_41600.n60 a_14540_41600.n59 18.4942
R4820 a_14540_41600.n41 a_14540_41600.n38 18.4942
R4821 a_14540_41600.n42 a_14540_41600.n37 18.4942
R4822 a_14540_41600.n43 a_14540_41600.n36 18.4942
R4823 a_14540_41600.n44 a_14540_41600.n35 18.4942
R4824 a_14540_41600.n45 a_14540_41600.n34 18.4942
R4825 a_14540_41600.n57 a_14540_41600.n56 18.4942
R4826 a_14540_41600.n55 a_14540_41600.n46 18.4942
R4827 a_14540_41600.n54 a_14540_41600.n53 18.4942
R4828 a_14540_41600.n52 a_14540_41600.n47 18.4942
R4829 a_14540_41600.n51 a_14540_41600.n50 18.4942
R4830 a_14540_41600.n29 a_14540_41600.n4 18.4942
R4831 a_14540_41600.n31 a_14540_41600.n30 18.4942
R4832 a_14540_41600.n12 a_14540_41600.n9 18.4942
R4833 a_14540_41600.n13 a_14540_41600.n8 18.4942
R4834 a_14540_41600.n14 a_14540_41600.n7 18.4942
R4835 a_14540_41600.n15 a_14540_41600.n6 18.4942
R4836 a_14540_41600.n16 a_14540_41600.n5 18.4942
R4837 a_14540_41600.n28 a_14540_41600.n27 18.4942
R4838 a_14540_41600.n26 a_14540_41600.n17 18.4942
R4839 a_14540_41600.n25 a_14540_41600.n24 18.4942
R4840 a_14540_41600.n23 a_14540_41600.n18 18.4942
R4841 a_14540_41600.n22 a_14540_41600.n21 18.4942
R4842 a_14540_41600.n70 a_14540_41600.n62 14.1358
R4843 a_14540_41600.n58 a_14540_41600.n57 11.6805
R4844 a_14540_41600.n59 a_14540_41600.n58 11.6805
R4845 a_14540_41600.n41 a_14540_41600.n40 11.6805
R4846 a_14540_41600.n42 a_14540_41600.n41 11.6805
R4847 a_14540_41600.n43 a_14540_41600.n42 11.6805
R4848 a_14540_41600.n44 a_14540_41600.n43 11.6805
R4849 a_14540_41600.n45 a_14540_41600.n44 11.6805
R4850 a_14540_41600.n59 a_14540_41600.n45 11.6805
R4851 a_14540_41600.n57 a_14540_41600.n46 11.6805
R4852 a_14540_41600.n53 a_14540_41600.n46 11.6805
R4853 a_14540_41600.n53 a_14540_41600.n52 11.6805
R4854 a_14540_41600.n52 a_14540_41600.n51 11.6805
R4855 a_14540_41600.n51 a_14540_41600.n48 11.6805
R4856 a_14540_41600.n29 a_14540_41600.n28 11.6805
R4857 a_14540_41600.n30 a_14540_41600.n29 11.6805
R4858 a_14540_41600.n12 a_14540_41600.n11 11.6805
R4859 a_14540_41600.n13 a_14540_41600.n12 11.6805
R4860 a_14540_41600.n14 a_14540_41600.n13 11.6805
R4861 a_14540_41600.n15 a_14540_41600.n14 11.6805
R4862 a_14540_41600.n16 a_14540_41600.n15 11.6805
R4863 a_14540_41600.n30 a_14540_41600.n16 11.6805
R4864 a_14540_41600.n28 a_14540_41600.n17 11.6805
R4865 a_14540_41600.n24 a_14540_41600.n17 11.6805
R4866 a_14540_41600.n24 a_14540_41600.n23 11.6805
R4867 a_14540_41600.n23 a_14540_41600.n22 11.6805
R4868 a_14540_41600.n22 a_14540_41600.n19 11.6805
R4869 a_14540_41600.n62 a_14540_41600.n32 10.688
R4870 a_14540_41600.n62 a_14540_41600.n61 9.24157
R4871 a_14540_41600.n50 a_14540_41600.n49 7.17687
R4872 a_14540_41600.n39 a_14540_41600.n38 7.17687
R4873 a_14540_41600.n21 a_14540_41600.n20 7.17687
R4874 a_14540_41600.n10 a_14540_41600.n9 7.17687
R4875 a_14540_41600.n71 a_14540_41600.n70 6.5392
R4876 a_14540_41600.n64 a_14540_41600.t6 5.7796
R4877 a_14540_41600.n1 a_14540_41600.t8 5.73764
R4878 a_14540_41600.n69 a_14540_41600.t15 5.59012
R4879 a_14540_41600.n71 a_14540_41600.t1 5.54817
R4880 a_14540_41600.n64 a_14540_41600.n63 5.38537
R4881 a_14540_41600.n66 a_14540_41600.n65 5.38537
R4882 a_14540_41600.n68 a_14540_41600.n67 5.38537
R4883 a_14540_41600.n73 a_14540_41600.n72 5.32067
R4884 a_14540_41600.n1 a_14540_41600.n0 5.32067
R4885 a_14540_41600.n3 a_14540_41600.n2 5.32067
R4886 a_14540_41600.n70 a_14540_41600.n69 4.61063
R4887 a_14540_41600.n40 a_14540_41600.n39 4.42851
R4888 a_14540_41600.n49 a_14540_41600.n48 4.42851
R4889 a_14540_41600.n11 a_14540_41600.n10 4.42851
R4890 a_14540_41600.n20 a_14540_41600.n19 4.42851
R4891 a_14540_41600.t0 a_14540_41600.n73 0.228
R4892 a_14540_41600.n73 a_14540_41600.t3 0.228
R4893 a_14540_41600.n0 a_14540_41600.t4 0.228
R4894 a_14540_41600.n0 a_14540_41600.t9 0.228
R4895 a_14540_41600.n2 a_14540_41600.t2 0.228
R4896 a_14540_41600.n2 a_14540_41600.t5 0.228
R4897 a_14540_41600.n63 a_14540_41600.t12 0.20525
R4898 a_14540_41600.n63 a_14540_41600.t7 0.20525
R4899 a_14540_41600.n65 a_14540_41600.t10 0.20525
R4900 a_14540_41600.n65 a_14540_41600.t13 0.20525
R4901 a_14540_41600.n67 a_14540_41600.t14 0.20525
R4902 a_14540_41600.n67 a_14540_41600.t11 0.20525
R4903 a_14540_41600.n72 a_14540_41600.n71 0.189974
R4904 a_14540_41600.n72 a_14540_41600.n3 0.189974
R4905 a_14540_41600.n3 a_14540_41600.n1 0.189974
R4906 a_14540_41600.n69 a_14540_41600.n68 0.189974
R4907 a_14540_41600.n68 a_14540_41600.n66 0.189974
R4908 a_14540_41600.n66 a_14540_41600.n64 0.189974
R4909 a_14540_41600.n56 a_14540_41600.n33 0.1205
R4910 a_14540_41600.n56 a_14540_41600.n55 0.1205
R4911 a_14540_41600.n55 a_14540_41600.n54 0.1205
R4912 a_14540_41600.n54 a_14540_41600.n47 0.1205
R4913 a_14540_41600.n50 a_14540_41600.n47 0.1205
R4914 a_14540_41600.n38 a_14540_41600.n37 0.1205
R4915 a_14540_41600.n37 a_14540_41600.n36 0.1205
R4916 a_14540_41600.n36 a_14540_41600.n35 0.1205
R4917 a_14540_41600.n35 a_14540_41600.n34 0.1205
R4918 a_14540_41600.n60 a_14540_41600.n34 0.1205
R4919 a_14540_41600.n27 a_14540_41600.n4 0.1205
R4920 a_14540_41600.n27 a_14540_41600.n26 0.1205
R4921 a_14540_41600.n26 a_14540_41600.n25 0.1205
R4922 a_14540_41600.n25 a_14540_41600.n18 0.1205
R4923 a_14540_41600.n21 a_14540_41600.n18 0.1205
R4924 a_14540_41600.n9 a_14540_41600.n8 0.1205
R4925 a_14540_41600.n8 a_14540_41600.n7 0.1205
R4926 a_14540_41600.n7 a_14540_41600.n6 0.1205
R4927 a_14540_41600.n6 a_14540_41600.n5 0.1205
R4928 a_14540_41600.n31 a_14540_41600.n5 0.1205
R4929 a_14540_41600.n61 a_14540_41600.n33 0.0485
R4930 a_14540_41600.n61 a_14540_41600.n60 0.0485
R4931 a_14540_41600.n32 a_14540_41600.n4 0.0485
R4932 a_14540_41600.n32 a_14540_41600.n31 0.0485
R4933 a_6924_41600.n18 a_6924_41600.t15 113.632
R4934 a_6924_41600.n22 a_6924_41600.t8 113.632
R4935 a_6924_41600.n5 a_6924_41600.t23 113.632
R4936 a_6924_41600.n9 a_6924_41600.t16 113.632
R4937 a_6924_41600.n25 a_6924_41600.t11 109.174
R4938 a_6924_41600.n26 a_6924_41600.t12 109.174
R4939 a_6924_41600.n19 a_6924_41600.t14 109.174
R4940 a_6924_41600.n20 a_6924_41600.t13 109.174
R4941 a_6924_41600.n24 a_6924_41600.t10 109.174
R4942 a_6924_41600.n21 a_6924_41600.t9 109.174
R4943 a_6924_41600.n12 a_6924_41600.t19 109.174
R4944 a_6924_41600.n13 a_6924_41600.t20 109.174
R4945 a_6924_41600.n6 a_6924_41600.t22 109.174
R4946 a_6924_41600.n7 a_6924_41600.t21 109.174
R4947 a_6924_41600.n11 a_6924_41600.t18 109.174
R4948 a_6924_41600.n8 a_6924_41600.t17 109.174
R4949 a_6924_41600.n25 a_6924_41600.n16 18.4942
R4950 a_6924_41600.n27 a_6924_41600.n26 18.4942
R4951 a_6924_41600.n20 a_6924_41600.n17 18.4942
R4952 a_6924_41600.n24 a_6924_41600.n23 18.4942
R4953 a_6924_41600.n12 a_6924_41600.n3 18.4942
R4954 a_6924_41600.n14 a_6924_41600.n13 18.4942
R4955 a_6924_41600.n7 a_6924_41600.n4 18.4942
R4956 a_6924_41600.n11 a_6924_41600.n10 18.4942
R4957 a_6924_41600.n30 a_6924_41600.n29 17.593
R4958 a_6924_41600.n25 a_6924_41600.n24 11.6805
R4959 a_6924_41600.n26 a_6924_41600.n25 11.6805
R4960 a_6924_41600.n20 a_6924_41600.n19 11.6805
R4961 a_6924_41600.n26 a_6924_41600.n20 11.6805
R4962 a_6924_41600.n24 a_6924_41600.n21 11.6805
R4963 a_6924_41600.n12 a_6924_41600.n11 11.6805
R4964 a_6924_41600.n13 a_6924_41600.n12 11.6805
R4965 a_6924_41600.n7 a_6924_41600.n6 11.6805
R4966 a_6924_41600.n13 a_6924_41600.n7 11.6805
R4967 a_6924_41600.n11 a_6924_41600.n8 11.6805
R4968 a_6924_41600.n29 a_6924_41600.n15 10.013
R4969 a_6924_41600.n29 a_6924_41600.n28 9.91657
R4970 a_6924_41600.n23 a_6924_41600.n22 7.17687
R4971 a_6924_41600.n18 a_6924_41600.n17 7.17687
R4972 a_6924_41600.n10 a_6924_41600.n9 7.17687
R4973 a_6924_41600.n5 a_6924_41600.n4 7.17687
R4974 a_6924_41600.n30 a_6924_41600.n2 6.5392
R4975 a_6924_41600.t3 a_6924_41600.n33 5.7796
R4976 a_6924_41600.n1 a_6924_41600.t7 5.73764
R4977 a_6924_41600.n31 a_6924_41600.t0 5.59012
R4978 a_6924_41600.n2 a_6924_41600.t4 5.54817
R4979 a_6924_41600.n33 a_6924_41600.n32 5.38537
R4980 a_6924_41600.n1 a_6924_41600.n0 5.32067
R4981 a_6924_41600.n31 a_6924_41600.n30 4.61063
R4982 a_6924_41600.n19 a_6924_41600.n18 4.42851
R4983 a_6924_41600.n22 a_6924_41600.n21 4.42851
R4984 a_6924_41600.n6 a_6924_41600.n5 4.42851
R4985 a_6924_41600.n9 a_6924_41600.n8 4.42851
R4986 a_6924_41600.n0 a_6924_41600.t5 0.228
R4987 a_6924_41600.n0 a_6924_41600.t6 0.228
R4988 a_6924_41600.n32 a_6924_41600.t1 0.20525
R4989 a_6924_41600.n32 a_6924_41600.t2 0.20525
R4990 a_6924_41600.n33 a_6924_41600.n31 0.189974
R4991 a_6924_41600.n2 a_6924_41600.n1 0.189974
R4992 a_6924_41600.n23 a_6924_41600.n16 0.1205
R4993 a_6924_41600.n27 a_6924_41600.n17 0.1205
R4994 a_6924_41600.n10 a_6924_41600.n3 0.1205
R4995 a_6924_41600.n14 a_6924_41600.n4 0.1205
R4996 a_6924_41600.n28 a_6924_41600.n16 0.0485
R4997 a_6924_41600.n28 a_6924_41600.n27 0.0485
R4998 a_6924_41600.n15 a_6924_41600.n3 0.0485
R4999 a_6924_41600.n15 a_6924_41600.n14 0.0485
R5000 a_4812_41600.n18 a_4812_41600.t15 113.632
R5001 a_4812_41600.n22 a_4812_41600.t8 113.632
R5002 a_4812_41600.n5 a_4812_41600.t23 113.632
R5003 a_4812_41600.n9 a_4812_41600.t16 113.632
R5004 a_4812_41600.n25 a_4812_41600.t11 109.174
R5005 a_4812_41600.n26 a_4812_41600.t12 109.174
R5006 a_4812_41600.n19 a_4812_41600.t14 109.174
R5007 a_4812_41600.n20 a_4812_41600.t13 109.174
R5008 a_4812_41600.n24 a_4812_41600.t10 109.174
R5009 a_4812_41600.n21 a_4812_41600.t9 109.174
R5010 a_4812_41600.n12 a_4812_41600.t19 109.174
R5011 a_4812_41600.n13 a_4812_41600.t20 109.174
R5012 a_4812_41600.n6 a_4812_41600.t22 109.174
R5013 a_4812_41600.n7 a_4812_41600.t21 109.174
R5014 a_4812_41600.n11 a_4812_41600.t18 109.174
R5015 a_4812_41600.n8 a_4812_41600.t17 109.174
R5016 a_4812_41600.n25 a_4812_41600.n16 18.4942
R5017 a_4812_41600.n27 a_4812_41600.n26 18.4942
R5018 a_4812_41600.n20 a_4812_41600.n17 18.4942
R5019 a_4812_41600.n24 a_4812_41600.n23 18.4942
R5020 a_4812_41600.n12 a_4812_41600.n3 18.4942
R5021 a_4812_41600.n14 a_4812_41600.n13 18.4942
R5022 a_4812_41600.n7 a_4812_41600.n4 18.4942
R5023 a_4812_41600.n11 a_4812_41600.n10 18.4942
R5024 a_4812_41600.n30 a_4812_41600.n29 17.3044
R5025 a_4812_41600.n25 a_4812_41600.n24 11.6805
R5026 a_4812_41600.n26 a_4812_41600.n25 11.6805
R5027 a_4812_41600.n20 a_4812_41600.n19 11.6805
R5028 a_4812_41600.n26 a_4812_41600.n20 11.6805
R5029 a_4812_41600.n24 a_4812_41600.n21 11.6805
R5030 a_4812_41600.n12 a_4812_41600.n11 11.6805
R5031 a_4812_41600.n13 a_4812_41600.n12 11.6805
R5032 a_4812_41600.n7 a_4812_41600.n6 11.6805
R5033 a_4812_41600.n13 a_4812_41600.n7 11.6805
R5034 a_4812_41600.n11 a_4812_41600.n8 11.6805
R5035 a_4812_41600.n29 a_4812_41600.n15 10.3505
R5036 a_4812_41600.n29 a_4812_41600.n28 9.57907
R5037 a_4812_41600.n23 a_4812_41600.n22 7.17687
R5038 a_4812_41600.n18 a_4812_41600.n17 7.17687
R5039 a_4812_41600.n10 a_4812_41600.n9 7.17687
R5040 a_4812_41600.n5 a_4812_41600.n4 7.17687
R5041 a_4812_41600.n30 a_4812_41600.n2 6.5392
R5042 a_4812_41600.t3 a_4812_41600.n33 5.7796
R5043 a_4812_41600.n1 a_4812_41600.t7 5.73764
R5044 a_4812_41600.n31 a_4812_41600.t0 5.59012
R5045 a_4812_41600.n2 a_4812_41600.t4 5.54817
R5046 a_4812_41600.n33 a_4812_41600.n32 5.38537
R5047 a_4812_41600.n1 a_4812_41600.n0 5.32067
R5048 a_4812_41600.n31 a_4812_41600.n30 4.61063
R5049 a_4812_41600.n19 a_4812_41600.n18 4.42851
R5050 a_4812_41600.n22 a_4812_41600.n21 4.42851
R5051 a_4812_41600.n6 a_4812_41600.n5 4.42851
R5052 a_4812_41600.n9 a_4812_41600.n8 4.42851
R5053 a_4812_41600.n0 a_4812_41600.t5 0.228
R5054 a_4812_41600.n0 a_4812_41600.t6 0.228
R5055 a_4812_41600.n32 a_4812_41600.t1 0.20525
R5056 a_4812_41600.n32 a_4812_41600.t2 0.20525
R5057 a_4812_41600.n33 a_4812_41600.n31 0.189974
R5058 a_4812_41600.n2 a_4812_41600.n1 0.189974
R5059 a_4812_41600.n23 a_4812_41600.n16 0.1205
R5060 a_4812_41600.n27 a_4812_41600.n17 0.1205
R5061 a_4812_41600.n10 a_4812_41600.n3 0.1205
R5062 a_4812_41600.n14 a_4812_41600.n4 0.1205
R5063 a_4812_41600.n28 a_4812_41600.n16 0.0485
R5064 a_4812_41600.n28 a_4812_41600.n27 0.0485
R5065 a_4812_41600.n15 a_4812_41600.n3 0.0485
R5066 a_4812_41600.n15 a_4812_41600.n14 0.0485
R5067 a_2700_41600.n18 a_2700_41600.t15 113.632
R5068 a_2700_41600.n22 a_2700_41600.t8 113.632
R5069 a_2700_41600.n5 a_2700_41600.t23 113.632
R5070 a_2700_41600.n9 a_2700_41600.t16 113.632
R5071 a_2700_41600.n25 a_2700_41600.t11 109.174
R5072 a_2700_41600.n26 a_2700_41600.t12 109.174
R5073 a_2700_41600.n19 a_2700_41600.t14 109.174
R5074 a_2700_41600.n20 a_2700_41600.t13 109.174
R5075 a_2700_41600.n24 a_2700_41600.t10 109.174
R5076 a_2700_41600.n21 a_2700_41600.t9 109.174
R5077 a_2700_41600.n12 a_2700_41600.t19 109.174
R5078 a_2700_41600.n13 a_2700_41600.t20 109.174
R5079 a_2700_41600.n6 a_2700_41600.t22 109.174
R5080 a_2700_41600.n7 a_2700_41600.t21 109.174
R5081 a_2700_41600.n11 a_2700_41600.t18 109.174
R5082 a_2700_41600.n8 a_2700_41600.t17 109.174
R5083 a_2700_41600.n25 a_2700_41600.n16 18.4942
R5084 a_2700_41600.n27 a_2700_41600.n26 18.4942
R5085 a_2700_41600.n20 a_2700_41600.n17 18.4942
R5086 a_2700_41600.n24 a_2700_41600.n23 18.4942
R5087 a_2700_41600.n12 a_2700_41600.n3 18.4942
R5088 a_2700_41600.n14 a_2700_41600.n13 18.4942
R5089 a_2700_41600.n7 a_2700_41600.n4 18.4942
R5090 a_2700_41600.n11 a_2700_41600.n10 18.4942
R5091 a_2700_41600.n30 a_2700_41600.n29 17.0158
R5092 a_2700_41600.n25 a_2700_41600.n24 11.6805
R5093 a_2700_41600.n26 a_2700_41600.n25 11.6805
R5094 a_2700_41600.n20 a_2700_41600.n19 11.6805
R5095 a_2700_41600.n26 a_2700_41600.n20 11.6805
R5096 a_2700_41600.n24 a_2700_41600.n21 11.6805
R5097 a_2700_41600.n12 a_2700_41600.n11 11.6805
R5098 a_2700_41600.n13 a_2700_41600.n12 11.6805
R5099 a_2700_41600.n7 a_2700_41600.n6 11.6805
R5100 a_2700_41600.n13 a_2700_41600.n7 11.6805
R5101 a_2700_41600.n11 a_2700_41600.n8 11.6805
R5102 a_2700_41600.n29 a_2700_41600.n15 10.688
R5103 a_2700_41600.n29 a_2700_41600.n28 9.24157
R5104 a_2700_41600.n23 a_2700_41600.n22 7.17687
R5105 a_2700_41600.n18 a_2700_41600.n17 7.17687
R5106 a_2700_41600.n10 a_2700_41600.n9 7.17687
R5107 a_2700_41600.n5 a_2700_41600.n4 7.17687
R5108 a_2700_41600.n30 a_2700_41600.n2 6.5392
R5109 a_2700_41600.t3 a_2700_41600.n33 5.7796
R5110 a_2700_41600.n1 a_2700_41600.t7 5.73764
R5111 a_2700_41600.n31 a_2700_41600.t0 5.59012
R5112 a_2700_41600.n2 a_2700_41600.t4 5.54817
R5113 a_2700_41600.n33 a_2700_41600.n32 5.38537
R5114 a_2700_41600.n1 a_2700_41600.n0 5.32067
R5115 a_2700_41600.n31 a_2700_41600.n30 4.61063
R5116 a_2700_41600.n19 a_2700_41600.n18 4.42851
R5117 a_2700_41600.n22 a_2700_41600.n21 4.42851
R5118 a_2700_41600.n6 a_2700_41600.n5 4.42851
R5119 a_2700_41600.n9 a_2700_41600.n8 4.42851
R5120 a_2700_41600.n0 a_2700_41600.t5 0.228
R5121 a_2700_41600.n0 a_2700_41600.t6 0.228
R5122 a_2700_41600.n32 a_2700_41600.t1 0.20525
R5123 a_2700_41600.n32 a_2700_41600.t2 0.20525
R5124 a_2700_41600.n33 a_2700_41600.n31 0.189974
R5125 a_2700_41600.n2 a_2700_41600.n1 0.189974
R5126 a_2700_41600.n23 a_2700_41600.n16 0.1205
R5127 a_2700_41600.n27 a_2700_41600.n17 0.1205
R5128 a_2700_41600.n10 a_2700_41600.n3 0.1205
R5129 a_2700_41600.n14 a_2700_41600.n4 0.1205
R5130 a_2700_41600.n28 a_2700_41600.n16 0.0485
R5131 a_2700_41600.n28 a_2700_41600.n27 0.0485
R5132 a_2700_41600.n15 a_2700_41600.n3 0.0485
R5133 a_2700_41600.n15 a_2700_41600.n14 0.0485
C0 VDD O_SENSE 80.5428f
C1 VDD CLKP_H 2.64315f
C2 VDD CLKN_H 2.64315f
C3 CLKP_HB CLKP_H 0.13381f
C4 CLKN_HB O_CAPTURE_CLKB 0.04486f
C5 O_CAPTURE_CLKB O_CAPTURE_CLK 0.13895f
C6 VDD CLKP_HB 3.0894f
C7 VDD E_SENSE 80.5428f
C8 VDD E_CAPTURE_CLK 11.2502f
C9 VDD E_CAPTURE_CLKB 11.3084f
C10 VDD CLKN_HB 3.0894f
C11 VDD O_CAPTURE_CLKB 11.3084f
C12 CLKN_HB CLKN_H 0.13381f
C13 CLKP_HB E_CAPTURE_CLKB 0.04486f
C14 VDD O_CAPTURE_CLK 11.2502f
C15 E_CAPTURE_CLKB E_CAPTURE_CLK 0.13895f
C16 E_SENSE VSS 85.11163f
C17 E_CAPTURE_CLK VSS 13.22096f
C18 E_CAPTURE_CLKB VSS 11.51597f
C19 CLKP_H VSS 8.80759f
C20 CLKP_HB VSS 10.42647f
C21 O_SENSE VSS 85.11163f
C22 O_CAPTURE_CLK VSS 13.22096f
C23 O_CAPTURE_CLKB VSS 11.51597f
C24 CLKN_H VSS 8.80759f
C25 CLKN_HB VSS 10.89567f
C26 VDD VSS 3.8105p
C27 a_2700_41600.t7 VSS 0.78846f
C28 a_2700_41600.t6 VSS 0.18273f
C29 a_2700_41600.t5 VSS 0.18273f
C30 a_2700_41600.n0 VSS 0.58157f
C31 a_2700_41600.n1 VSS 0.31967f
C32 a_2700_41600.t4 VSS 0.78325f
C33 a_2700_41600.n2 VSS 0.34526f
C34 a_2700_41600.n3 VSS 0.05376f
C35 a_2700_41600.n4 VSS 0.18572f
C36 a_2700_41600.n5 VSS 0.0918f
C37 a_2700_41600.n6 VSS 0.0984f
C38 a_2700_41600.n7 VSS 0.0984f
C39 a_2700_41600.n8 VSS 0.0984f
C40 a_2700_41600.n9 VSS 0.0918f
C41 a_2700_41600.n10 VSS 0.18572f
C42 a_2700_41600.n11 VSS 0.0984f
C43 a_2700_41600.n12 VSS 0.0984f
C44 a_2700_41600.n13 VSS 0.0984f
C45 a_2700_41600.n14 VSS 0.05376f
C46 a_2700_41600.n15 VSS 0.30181f
C47 a_2700_41600.n16 VSS 0.05376f
C48 a_2700_41600.n17 VSS 0.18572f
C49 a_2700_41600.n18 VSS 0.0918f
C50 a_2700_41600.n19 VSS 0.0984f
C51 a_2700_41600.n20 VSS 0.0984f
C52 a_2700_41600.n21 VSS 0.0984f
C53 a_2700_41600.n22 VSS 0.0918f
C54 a_2700_41600.n23 VSS 0.18572f
C55 a_2700_41600.n24 VSS 0.0984f
C56 a_2700_41600.n25 VSS 0.0984f
C57 a_2700_41600.n26 VSS 0.0984f
C58 a_2700_41600.n27 VSS 0.05376f
C59 a_2700_41600.n28 VSS 0.22605f
C60 a_2700_41600.n29 VSS 2.02655f
C61 a_2700_41600.n30 VSS 1.88452f
C62 a_2700_41600.t0 VSS 0.78185f
C63 a_2700_41600.n31 VSS 0.23411f
C64 a_2700_41600.t2 VSS 0.18273f
C65 a_2700_41600.t1 VSS 0.18273f
C66 a_2700_41600.n32 VSS 0.57729f
C67 a_2700_41600.n33 VSS 0.32535f
C68 a_2700_41600.t3 VSS 0.78708f
C69 a_4812_41600.t7 VSS 0.80734f
C70 a_4812_41600.t6 VSS 0.1763f
C71 a_4812_41600.t5 VSS 0.1763f
C72 a_4812_41600.n0 VSS 0.60614f
C73 a_4812_41600.n1 VSS 0.33317f
C74 a_4812_41600.t4 VSS 0.8019f
C75 a_4812_41600.n2 VSS 0.35985f
C76 a_4812_41600.n3 VSS 0.05603f
C77 a_4812_41600.n4 VSS 0.19357f
C78 a_4812_41600.n5 VSS 0.09568f
C79 a_4812_41600.n6 VSS 0.10256f
C80 a_4812_41600.n7 VSS 0.10256f
C81 a_4812_41600.n8 VSS 0.10256f
C82 a_4812_41600.n9 VSS 0.09568f
C83 a_4812_41600.n10 VSS 0.19357f
C84 a_4812_41600.n11 VSS 0.10256f
C85 a_4812_41600.n12 VSS 0.10256f
C86 a_4812_41600.n13 VSS 0.10256f
C87 a_4812_41600.n14 VSS 0.05603f
C88 a_4812_41600.n15 VSS 0.29102f
C89 a_4812_41600.n16 VSS 0.05603f
C90 a_4812_41600.n17 VSS 0.19357f
C91 a_4812_41600.n18 VSS 0.09568f
C92 a_4812_41600.n19 VSS 0.10256f
C93 a_4812_41600.n20 VSS 0.10256f
C94 a_4812_41600.n21 VSS 0.10256f
C95 a_4812_41600.n22 VSS 0.09568f
C96 a_4812_41600.n23 VSS 0.19357f
C97 a_4812_41600.n24 VSS 0.10256f
C98 a_4812_41600.n25 VSS 0.10256f
C99 a_4812_41600.n26 VSS 0.10256f
C100 a_4812_41600.n27 VSS 0.05603f
C101 a_4812_41600.n28 VSS 0.24849f
C102 a_4812_41600.n29 VSS 2.18227f
C103 a_4812_41600.n30 VSS 1.93796f
C104 a_4812_41600.t0 VSS 0.80045f
C105 a_4812_41600.n31 VSS 0.244f
C106 a_4812_41600.t2 VSS 0.1763f
C107 a_4812_41600.t1 VSS 0.1763f
C108 a_4812_41600.n32 VSS 0.60167f
C109 a_4812_41600.n33 VSS 0.33909f
C110 a_4812_41600.t3 VSS 0.8059f
C111 a_6924_41600.t7 VSS 0.80452f
C112 a_6924_41600.t6 VSS 0.18525f
C113 a_6924_41600.t5 VSS 0.18525f
C114 a_6924_41600.n0 VSS 0.5946f
C115 a_6924_41600.n1 VSS 0.32684f
C116 a_6924_41600.t4 VSS 0.79919f
C117 a_6924_41600.n2 VSS 0.353f
C118 a_6924_41600.n3 VSS 0.05497f
C119 a_6924_41600.n4 VSS 0.18988f
C120 a_6924_41600.n5 VSS 0.09386f
C121 a_6924_41600.n6 VSS 0.10061f
C122 a_6924_41600.n7 VSS 0.10061f
C123 a_6924_41600.n8 VSS 0.10061f
C124 a_6924_41600.n9 VSS 0.09386f
C125 a_6924_41600.n10 VSS 0.18988f
C126 a_6924_41600.n11 VSS 0.10061f
C127 a_6924_41600.n12 VSS 0.10061f
C128 a_6924_41600.n13 VSS 0.10061f
C129 a_6924_41600.n14 VSS 0.05497f
C130 a_6924_41600.n15 VSS 0.2652f
C131 a_6924_41600.n16 VSS 0.05497f
C132 a_6924_41600.n17 VSS 0.18988f
C133 a_6924_41600.n18 VSS 0.09386f
C134 a_6924_41600.n19 VSS 0.10061f
C135 a_6924_41600.n20 VSS 0.10061f
C136 a_6924_41600.n21 VSS 0.10061f
C137 a_6924_41600.n22 VSS 0.09386f
C138 a_6924_41600.n23 VSS 0.18988f
C139 a_6924_41600.n24 VSS 0.10061f
C140 a_6924_41600.n25 VSS 0.10061f
C141 a_6924_41600.n26 VSS 0.10061f
C142 a_6924_41600.n27 VSS 0.05497f
C143 a_6924_41600.n28 VSS 0.25997f
C144 a_6924_41600.n29 VSS 2.20328f
C145 a_6924_41600.n30 VSS 1.87531f
C146 a_6924_41600.t0 VSS 0.79776f
C147 a_6924_41600.n31 VSS 0.23936f
C148 a_6924_41600.t2 VSS 0.18525f
C149 a_6924_41600.t1 VSS 0.18525f
C150 a_6924_41600.n32 VSS 0.59022f
C151 a_6924_41600.n33 VSS 0.33264f
C152 a_6924_41600.t3 VSS 0.8031f
C153 a_14540_41600.t3 VSS 0.2088f
C154 a_14540_41600.t8 VSS 0.8086f
C155 a_14540_41600.t9 VSS 0.2088f
C156 a_14540_41600.t4 VSS 0.2088f
C157 a_14540_41600.n0 VSS 0.57536f
C158 a_14540_41600.n1 VSS 0.31626f
C159 a_14540_41600.t5 VSS 0.2088f
C160 a_14540_41600.t2 VSS 0.2088f
C161 a_14540_41600.n2 VSS 0.57536f
C162 a_14540_41600.n3 VSS 0.16509f
C163 a_14540_41600.n4 VSS 0.05319f
C164 a_14540_41600.n5 VSS 0.06313f
C165 a_14540_41600.n6 VSS 0.06313f
C166 a_14540_41600.n7 VSS 0.06313f
C167 a_14540_41600.n8 VSS 0.06313f
C168 a_14540_41600.n9 VSS 0.18374f
C169 a_14540_41600.n10 VSS 0.09082f
C170 a_14540_41600.n11 VSS 0.09735f
C171 a_14540_41600.n12 VSS 0.09735f
C172 a_14540_41600.n13 VSS 0.09735f
C173 a_14540_41600.n14 VSS 0.09735f
C174 a_14540_41600.n15 VSS 0.09735f
C175 a_14540_41600.n16 VSS 0.09735f
C176 a_14540_41600.n17 VSS 0.09735f
C177 a_14540_41600.n18 VSS 0.06313f
C178 a_14540_41600.n19 VSS 0.09735f
C179 a_14540_41600.n20 VSS 0.09082f
C180 a_14540_41600.n21 VSS 0.18374f
C181 a_14540_41600.n22 VSS 0.09735f
C182 a_14540_41600.n23 VSS 0.09735f
C183 a_14540_41600.n24 VSS 0.09735f
C184 a_14540_41600.n25 VSS 0.06313f
C185 a_14540_41600.n26 VSS 0.06313f
C186 a_14540_41600.n27 VSS 0.06313f
C187 a_14540_41600.n28 VSS 0.09735f
C188 a_14540_41600.n29 VSS 0.09735f
C189 a_14540_41600.n30 VSS 0.09735f
C190 a_14540_41600.n31 VSS 0.05319f
C191 a_14540_41600.n32 VSS 0.52036f
C192 a_14540_41600.n33 VSS 0.05319f
C193 a_14540_41600.n34 VSS 0.06313f
C194 a_14540_41600.n35 VSS 0.06313f
C195 a_14540_41600.n36 VSS 0.06313f
C196 a_14540_41600.n37 VSS 0.06313f
C197 a_14540_41600.n38 VSS 0.18374f
C198 a_14540_41600.n39 VSS 0.09082f
C199 a_14540_41600.n40 VSS 0.09735f
C200 a_14540_41600.n41 VSS 0.09735f
C201 a_14540_41600.n42 VSS 0.09735f
C202 a_14540_41600.n43 VSS 0.09735f
C203 a_14540_41600.n44 VSS 0.09735f
C204 a_14540_41600.n45 VSS 0.09735f
C205 a_14540_41600.n46 VSS 0.09735f
C206 a_14540_41600.n47 VSS 0.06313f
C207 a_14540_41600.n48 VSS 0.09735f
C208 a_14540_41600.n49 VSS 0.09082f
C209 a_14540_41600.n50 VSS 0.18374f
C210 a_14540_41600.n51 VSS 0.09735f
C211 a_14540_41600.n52 VSS 0.09735f
C212 a_14540_41600.n53 VSS 0.09735f
C213 a_14540_41600.n54 VSS 0.06313f
C214 a_14540_41600.n55 VSS 0.06313f
C215 a_14540_41600.n56 VSS 0.06313f
C216 a_14540_41600.n57 VSS 0.09735f
C217 a_14540_41600.n58 VSS 0.09735f
C218 a_14540_41600.n59 VSS 0.09735f
C219 a_14540_41600.n60 VSS 0.05319f
C220 a_14540_41600.n61 VSS 0.42016f
C221 a_14540_41600.n62 VSS 1.97824f
C222 a_14540_41600.t6 VSS 0.80723f
C223 a_14540_41600.t7 VSS 0.2088f
C224 a_14540_41600.t12 VSS 0.2088f
C225 a_14540_41600.n63 VSS 0.57112f
C226 a_14540_41600.n64 VSS 0.32187f
C227 a_14540_41600.t13 VSS 0.2088f
C228 a_14540_41600.t10 VSS 0.2088f
C229 a_14540_41600.n65 VSS 0.57112f
C230 a_14540_41600.n66 VSS 0.16934f
C231 a_14540_41600.t11 VSS 0.2088f
C232 a_14540_41600.t14 VSS 0.2088f
C233 a_14540_41600.n67 VSS 0.57112f
C234 a_14540_41600.n68 VSS 0.16934f
C235 a_14540_41600.t15 VSS 0.80206f
C236 a_14540_41600.n69 VSS 0.23161f
C237 a_14540_41600.n70 VSS 1.51516f
C238 a_14540_41600.t1 VSS 0.80344f
C239 a_14540_41600.n71 VSS 0.34157f
C240 a_14540_41600.n72 VSS 0.16509f
C241 a_14540_41600.n73 VSS 0.57536f
C242 a_14540_41600.t0 VSS 0.2088f
C243 a_17292_41600.t7 VSS 0.20563f
C244 a_17292_41600.t8 VSS 0.80533f
C245 a_17292_41600.t9 VSS 0.20563f
C246 a_17292_41600.t22 VSS 0.20563f
C247 a_17292_41600.n0 VSS 0.57532f
C248 a_17292_41600.n1 VSS 0.31624f
C249 a_17292_41600.t23 VSS 0.20563f
C250 a_17292_41600.t2 VSS 0.20563f
C251 a_17292_41600.n2 VSS 0.57532f
C252 a_17292_41600.n3 VSS 0.16508f
C253 a_17292_41600.t3 VSS 0.20563f
C254 a_17292_41600.t4 VSS 0.20563f
C255 a_17292_41600.n4 VSS 0.57532f
C256 a_17292_41600.n5 VSS 0.16508f
C257 a_17292_41600.t5 VSS 0.20563f
C258 a_17292_41600.t6 VSS 0.20563f
C259 a_17292_41600.n6 VSS 0.57532f
C260 a_17292_41600.n7 VSS 0.16508f
C261 a_17292_41600.n8 VSS 0.05318f
C262 a_17292_41600.n9 VSS 0.06312f
C263 a_17292_41600.n10 VSS 0.06312f
C264 a_17292_41600.n11 VSS 0.06312f
C265 a_17292_41600.n12 VSS 0.06312f
C266 a_17292_41600.n13 VSS 0.06312f
C267 a_17292_41600.n14 VSS 0.06312f
C268 a_17292_41600.n15 VSS 0.06312f
C269 a_17292_41600.n16 VSS 0.06312f
C270 a_17292_41600.n17 VSS 0.06312f
C271 a_17292_41600.n18 VSS 0.06312f
C272 a_17292_41600.n19 VSS 0.06312f
C273 a_17292_41600.n20 VSS 0.06312f
C274 a_17292_41600.n21 VSS 0.18373f
C275 a_17292_41600.n22 VSS 0.09081f
C276 a_17292_41600.n23 VSS 0.09734f
C277 a_17292_41600.n24 VSS 0.09734f
C278 a_17292_41600.n25 VSS 0.09734f
C279 a_17292_41600.n26 VSS 0.09734f
C280 a_17292_41600.n27 VSS 0.09734f
C281 a_17292_41600.n28 VSS 0.09734f
C282 a_17292_41600.n29 VSS 0.09734f
C283 a_17292_41600.n30 VSS 0.09734f
C284 a_17292_41600.n31 VSS 0.09734f
C285 a_17292_41600.n32 VSS 0.09734f
C286 a_17292_41600.n33 VSS 0.09734f
C287 a_17292_41600.n34 VSS 0.09734f
C288 a_17292_41600.n35 VSS 0.09734f
C289 a_17292_41600.n36 VSS 0.09734f
C290 a_17292_41600.n37 VSS 0.09734f
C291 a_17292_41600.n38 VSS 0.06312f
C292 a_17292_41600.n39 VSS 0.09734f
C293 a_17292_41600.n40 VSS 0.06312f
C294 a_17292_41600.n41 VSS 0.09734f
C295 a_17292_41600.n42 VSS 0.06312f
C296 a_17292_41600.n43 VSS 0.09734f
C297 a_17292_41600.n44 VSS 0.09081f
C298 a_17292_41600.n45 VSS 0.18373f
C299 a_17292_41600.n46 VSS 0.09734f
C300 a_17292_41600.n47 VSS 0.09734f
C301 a_17292_41600.n48 VSS 0.09734f
C302 a_17292_41600.n49 VSS 0.06312f
C303 a_17292_41600.n50 VSS 0.06312f
C304 a_17292_41600.n51 VSS 0.06312f
C305 a_17292_41600.n52 VSS 0.09734f
C306 a_17292_41600.n53 VSS 0.09734f
C307 a_17292_41600.n54 VSS 0.09734f
C308 a_17292_41600.n55 VSS 0.06312f
C309 a_17292_41600.n56 VSS 0.06312f
C310 a_17292_41600.n57 VSS 0.06312f
C311 a_17292_41600.n58 VSS 0.09734f
C312 a_17292_41600.n59 VSS 0.09734f
C313 a_17292_41600.n60 VSS 0.09734f
C314 a_17292_41600.n61 VSS 0.06312f
C315 a_17292_41600.n62 VSS 0.06312f
C316 a_17292_41600.n63 VSS 0.06312f
C317 a_17292_41600.n64 VSS 0.09734f
C318 a_17292_41600.n65 VSS 0.09734f
C319 a_17292_41600.n66 VSS 0.09734f
C320 a_17292_41600.n67 VSS 0.05318f
C321 a_17292_41600.n68 VSS 0.99199f
C322 a_17292_41600.n69 VSS 0.05318f
C323 a_17292_41600.n70 VSS 0.06312f
C324 a_17292_41600.n71 VSS 0.06312f
C325 a_17292_41600.n72 VSS 0.06312f
C326 a_17292_41600.n73 VSS 0.06312f
C327 a_17292_41600.n74 VSS 0.06312f
C328 a_17292_41600.n75 VSS 0.06312f
C329 a_17292_41600.n76 VSS 0.06312f
C330 a_17292_41600.n77 VSS 0.06312f
C331 a_17292_41600.n78 VSS 0.06312f
C332 a_17292_41600.n79 VSS 0.06312f
C333 a_17292_41600.n80 VSS 0.06312f
C334 a_17292_41600.n81 VSS 0.06312f
C335 a_17292_41600.n82 VSS 0.18373f
C336 a_17292_41600.n83 VSS 0.09081f
C337 a_17292_41600.n84 VSS 0.09734f
C338 a_17292_41600.n85 VSS 0.09734f
C339 a_17292_41600.n86 VSS 0.09734f
C340 a_17292_41600.n87 VSS 0.09734f
C341 a_17292_41600.n88 VSS 0.09734f
C342 a_17292_41600.n89 VSS 0.09734f
C343 a_17292_41600.n90 VSS 0.09734f
C344 a_17292_41600.n91 VSS 0.09734f
C345 a_17292_41600.n92 VSS 0.09734f
C346 a_17292_41600.n93 VSS 0.09734f
C347 a_17292_41600.n94 VSS 0.09734f
C348 a_17292_41600.n95 VSS 0.09734f
C349 a_17292_41600.n96 VSS 0.09734f
C350 a_17292_41600.n97 VSS 0.09734f
C351 a_17292_41600.n98 VSS 0.09734f
C352 a_17292_41600.n99 VSS 0.06312f
C353 a_17292_41600.n100 VSS 0.09734f
C354 a_17292_41600.n101 VSS 0.06312f
C355 a_17292_41600.n102 VSS 0.09734f
C356 a_17292_41600.n103 VSS 0.06312f
C357 a_17292_41600.n104 VSS 0.09734f
C358 a_17292_41600.n105 VSS 0.09081f
C359 a_17292_41600.n106 VSS 0.18373f
C360 a_17292_41600.n107 VSS 0.09734f
C361 a_17292_41600.n108 VSS 0.09734f
C362 a_17292_41600.n109 VSS 0.09734f
C363 a_17292_41600.n110 VSS 0.06312f
C364 a_17292_41600.n111 VSS 0.06312f
C365 a_17292_41600.n112 VSS 0.06312f
C366 a_17292_41600.n113 VSS 0.09734f
C367 a_17292_41600.n114 VSS 0.09734f
C368 a_17292_41600.n115 VSS 0.09734f
C369 a_17292_41600.n116 VSS 0.06312f
C370 a_17292_41600.n117 VSS 0.06312f
C371 a_17292_41600.n118 VSS 0.06312f
C372 a_17292_41600.n119 VSS 0.09734f
C373 a_17292_41600.n120 VSS 0.09734f
C374 a_17292_41600.n121 VSS 0.09734f
C375 a_17292_41600.n122 VSS 0.06312f
C376 a_17292_41600.n123 VSS 0.06312f
C377 a_17292_41600.n124 VSS 0.06312f
C378 a_17292_41600.n125 VSS 0.09734f
C379 a_17292_41600.n126 VSS 0.09734f
C380 a_17292_41600.n127 VSS 0.09734f
C381 a_17292_41600.n128 VSS 0.05318f
C382 a_17292_41600.n129 VSS 0.79175f
C383 a_17292_41600.n130 VSS 3.04808f
C384 a_17292_41600.t10 VSS 0.80396f
C385 a_17292_41600.t11 VSS 0.20563f
C386 a_17292_41600.t24 VSS 0.20563f
C387 a_17292_41600.n131 VSS 0.57108f
C388 a_17292_41600.n132 VSS 0.32185f
C389 a_17292_41600.t25 VSS 0.20563f
C390 a_17292_41600.t26 VSS 0.20563f
C391 a_17292_41600.n133 VSS 0.57108f
C392 a_17292_41600.n134 VSS 0.16932f
C393 a_17292_41600.t27 VSS 0.20563f
C394 a_17292_41600.t28 VSS 0.20563f
C395 a_17292_41600.n135 VSS 0.57108f
C396 a_17292_41600.n136 VSS 0.16932f
C397 a_17292_41600.t29 VSS 0.20563f
C398 a_17292_41600.t18 VSS 0.20563f
C399 a_17292_41600.n137 VSS 0.57108f
C400 a_17292_41600.n138 VSS 0.16932f
C401 a_17292_41600.t19 VSS 0.20563f
C402 a_17292_41600.t14 VSS 0.20563f
C403 a_17292_41600.n139 VSS 0.57108f
C404 a_17292_41600.n140 VSS 0.16932f
C405 a_17292_41600.t15 VSS 0.20563f
C406 a_17292_41600.t16 VSS 0.20563f
C407 a_17292_41600.n141 VSS 0.57108f
C408 a_17292_41600.n142 VSS 0.16932f
C409 a_17292_41600.t17 VSS 0.20563f
C410 a_17292_41600.t12 VSS 0.20563f
C411 a_17292_41600.n143 VSS 0.57108f
C412 a_17292_41600.n144 VSS 0.16932f
C413 a_17292_41600.t13 VSS 0.79879f
C414 a_17292_41600.n145 VSS 0.23159f
C415 a_17292_41600.n146 VSS 1.92476f
C416 a_17292_41600.t31 VSS 0.80017f
C417 a_17292_41600.n147 VSS 0.34155f
C418 a_17292_41600.t21 VSS 0.20563f
C419 a_17292_41600.t30 VSS 0.20563f
C420 a_17292_41600.n148 VSS 0.57532f
C421 a_17292_41600.n149 VSS 0.16508f
C422 a_17292_41600.t1 VSS 0.20563f
C423 a_17292_41600.t20 VSS 0.20563f
C424 a_17292_41600.n150 VSS 0.57532f
C425 a_17292_41600.n151 VSS 0.16508f
C426 a_17292_41600.n152 VSS 0.16508f
C427 a_17292_41600.n153 VSS 0.57532f
C428 a_17292_41600.t0 VSS 0.20563f
C429 a_21324_41600.t42 VSS 0.20776f
C430 a_21324_41600.t44 VSS 0.81892f
C431 a_21324_41600.t30 VSS 0.20776f
C432 a_21324_41600.t43 VSS 0.20776f
C433 a_21324_41600.n0 VSS 0.58635f
C434 a_21324_41600.n1 VSS 0.3223f
C435 a_21324_41600.t17 VSS 0.20776f
C436 a_21324_41600.t12 VSS 0.20776f
C437 a_21324_41600.n2 VSS 0.58635f
C438 a_21324_41600.n3 VSS 0.16825f
C439 a_21324_41600.t48 VSS 0.20776f
C440 a_21324_41600.t39 VSS 0.20776f
C441 a_21324_41600.n4 VSS 0.58635f
C442 a_21324_41600.n5 VSS 0.16825f
C443 a_21324_41600.t61 VSS 0.20776f
C444 a_21324_41600.t9 VSS 0.20776f
C445 a_21324_41600.n6 VSS 0.58635f
C446 a_21324_41600.n7 VSS 0.16825f
C447 a_21324_41600.t53 VSS 0.20776f
C448 a_21324_41600.t36 VSS 0.20776f
C449 a_21324_41600.n8 VSS 0.58635f
C450 a_21324_41600.n9 VSS 0.16825f
C451 a_21324_41600.n10 VSS 0.0542f
C452 a_21324_41600.n11 VSS 0.06433f
C453 a_21324_41600.n12 VSS 0.06433f
C454 a_21324_41600.n13 VSS 0.06433f
C455 a_21324_41600.n14 VSS 0.06433f
C456 a_21324_41600.n15 VSS 0.06433f
C457 a_21324_41600.n16 VSS 0.06433f
C458 a_21324_41600.n17 VSS 0.06433f
C459 a_21324_41600.n18 VSS 0.06433f
C460 a_21324_41600.n19 VSS 0.06433f
C461 a_21324_41600.n20 VSS 0.06433f
C462 a_21324_41600.n21 VSS 0.06433f
C463 a_21324_41600.n22 VSS 0.06433f
C464 a_21324_41600.n23 VSS 0.06433f
C465 a_21324_41600.n24 VSS 0.06433f
C466 a_21324_41600.n25 VSS 0.06433f
C467 a_21324_41600.n26 VSS 0.06433f
C468 a_21324_41600.n27 VSS 0.06433f
C469 a_21324_41600.n28 VSS 0.06433f
C470 a_21324_41600.n29 VSS 0.06433f
C471 a_21324_41600.n30 VSS 0.06433f
C472 a_21324_41600.n31 VSS 0.06433f
C473 a_21324_41600.n32 VSS 0.06433f
C474 a_21324_41600.n33 VSS 0.06433f
C475 a_21324_41600.n34 VSS 0.06433f
C476 a_21324_41600.n35 VSS 0.06433f
C477 a_21324_41600.n36 VSS 0.06433f
C478 a_21324_41600.n37 VSS 0.06433f
C479 a_21324_41600.n38 VSS 0.06433f
C480 a_21324_41600.n39 VSS 0.18725f
C481 a_21324_41600.n40 VSS 0.09255f
C482 a_21324_41600.n41 VSS 0.09921f
C483 a_21324_41600.n42 VSS 0.09921f
C484 a_21324_41600.n43 VSS 0.09921f
C485 a_21324_41600.n44 VSS 0.09921f
C486 a_21324_41600.n45 VSS 0.09921f
C487 a_21324_41600.n46 VSS 0.09921f
C488 a_21324_41600.n47 VSS 0.09921f
C489 a_21324_41600.n48 VSS 0.09921f
C490 a_21324_41600.n49 VSS 0.09921f
C491 a_21324_41600.n50 VSS 0.09921f
C492 a_21324_41600.n51 VSS 0.09921f
C493 a_21324_41600.n52 VSS 0.09921f
C494 a_21324_41600.n53 VSS 0.09921f
C495 a_21324_41600.n54 VSS 0.09921f
C496 a_21324_41600.n55 VSS 0.09921f
C497 a_21324_41600.n56 VSS 0.09921f
C498 a_21324_41600.n57 VSS 0.09921f
C499 a_21324_41600.n58 VSS 0.09921f
C500 a_21324_41600.n59 VSS 0.09921f
C501 a_21324_41600.n60 VSS 0.09921f
C502 a_21324_41600.n61 VSS 0.09921f
C503 a_21324_41600.n62 VSS 0.09921f
C504 a_21324_41600.n63 VSS 0.09921f
C505 a_21324_41600.n64 VSS 0.09921f
C506 a_21324_41600.n65 VSS 0.09921f
C507 a_21324_41600.n66 VSS 0.09921f
C508 a_21324_41600.n67 VSS 0.09921f
C509 a_21324_41600.n68 VSS 0.09921f
C510 a_21324_41600.n69 VSS 0.09921f
C511 a_21324_41600.n70 VSS 0.09921f
C512 a_21324_41600.n71 VSS 0.09921f
C513 a_21324_41600.n72 VSS 0.06433f
C514 a_21324_41600.n73 VSS 0.09921f
C515 a_21324_41600.n74 VSS 0.06433f
C516 a_21324_41600.n75 VSS 0.09921f
C517 a_21324_41600.n76 VSS 0.06433f
C518 a_21324_41600.n77 VSS 0.09921f
C519 a_21324_41600.n78 VSS 0.06433f
C520 a_21324_41600.n79 VSS 0.09921f
C521 a_21324_41600.n80 VSS 0.06433f
C522 a_21324_41600.n81 VSS 0.09921f
C523 a_21324_41600.n82 VSS 0.06433f
C524 a_21324_41600.n83 VSS 0.09921f
C525 a_21324_41600.n84 VSS 0.06433f
C526 a_21324_41600.n85 VSS 0.09921f
C527 a_21324_41600.n86 VSS 0.09255f
C528 a_21324_41600.n87 VSS 0.18725f
C529 a_21324_41600.n88 VSS 0.09921f
C530 a_21324_41600.n89 VSS 0.09921f
C531 a_21324_41600.n90 VSS 0.09921f
C532 a_21324_41600.n91 VSS 0.06433f
C533 a_21324_41600.n92 VSS 0.06433f
C534 a_21324_41600.n93 VSS 0.06433f
C535 a_21324_41600.n94 VSS 0.09921f
C536 a_21324_41600.n95 VSS 0.09921f
C537 a_21324_41600.n96 VSS 0.09921f
C538 a_21324_41600.n97 VSS 0.06433f
C539 a_21324_41600.n98 VSS 0.06433f
C540 a_21324_41600.n99 VSS 0.06433f
C541 a_21324_41600.n100 VSS 0.09921f
C542 a_21324_41600.n101 VSS 0.09921f
C543 a_21324_41600.n102 VSS 0.09921f
C544 a_21324_41600.n103 VSS 0.06433f
C545 a_21324_41600.n104 VSS 0.06433f
C546 a_21324_41600.n105 VSS 0.06433f
C547 a_21324_41600.n106 VSS 0.09921f
C548 a_21324_41600.n107 VSS 0.09921f
C549 a_21324_41600.n108 VSS 0.09921f
C550 a_21324_41600.n109 VSS 0.06433f
C551 a_21324_41600.n110 VSS 0.06433f
C552 a_21324_41600.n111 VSS 0.06433f
C553 a_21324_41600.n112 VSS 0.09921f
C554 a_21324_41600.n113 VSS 0.09921f
C555 a_21324_41600.n114 VSS 0.09921f
C556 a_21324_41600.n115 VSS 0.06433f
C557 a_21324_41600.n116 VSS 0.06433f
C558 a_21324_41600.n117 VSS 0.06433f
C559 a_21324_41600.n118 VSS 0.09921f
C560 a_21324_41600.n119 VSS 0.09921f
C561 a_21324_41600.n120 VSS 0.09921f
C562 a_21324_41600.n121 VSS 0.06433f
C563 a_21324_41600.n122 VSS 0.06433f
C564 a_21324_41600.n123 VSS 0.06433f
C565 a_21324_41600.n124 VSS 0.09921f
C566 a_21324_41600.n125 VSS 0.09921f
C567 a_21324_41600.n126 VSS 0.09921f
C568 a_21324_41600.n127 VSS 0.06433f
C569 a_21324_41600.n128 VSS 0.06433f
C570 a_21324_41600.n129 VSS 0.06433f
C571 a_21324_41600.n130 VSS 0.09921f
C572 a_21324_41600.n131 VSS 0.09921f
C573 a_21324_41600.n132 VSS 0.09921f
C574 a_21324_41600.n133 VSS 0.0542f
C575 a_21324_41600.n134 VSS 1.82602f
C576 a_21324_41600.n135 VSS 0.0542f
C577 a_21324_41600.n136 VSS 0.06433f
C578 a_21324_41600.n137 VSS 0.06433f
C579 a_21324_41600.n138 VSS 0.06433f
C580 a_21324_41600.n139 VSS 0.06433f
C581 a_21324_41600.n140 VSS 0.06433f
C582 a_21324_41600.n141 VSS 0.06433f
C583 a_21324_41600.n142 VSS 0.06433f
C584 a_21324_41600.n143 VSS 0.06433f
C585 a_21324_41600.n144 VSS 0.06433f
C586 a_21324_41600.n145 VSS 0.06433f
C587 a_21324_41600.n146 VSS 0.06433f
C588 a_21324_41600.n147 VSS 0.06433f
C589 a_21324_41600.n148 VSS 0.06433f
C590 a_21324_41600.n149 VSS 0.06433f
C591 a_21324_41600.n150 VSS 0.06433f
C592 a_21324_41600.n151 VSS 0.06433f
C593 a_21324_41600.n152 VSS 0.06433f
C594 a_21324_41600.n153 VSS 0.06433f
C595 a_21324_41600.n154 VSS 0.06433f
C596 a_21324_41600.n155 VSS 0.06433f
C597 a_21324_41600.n156 VSS 0.06433f
C598 a_21324_41600.n157 VSS 0.06433f
C599 a_21324_41600.n158 VSS 0.06433f
C600 a_21324_41600.n159 VSS 0.06433f
C601 a_21324_41600.n160 VSS 0.06433f
C602 a_21324_41600.n161 VSS 0.06433f
C603 a_21324_41600.n162 VSS 0.06433f
C604 a_21324_41600.n163 VSS 0.06433f
C605 a_21324_41600.n164 VSS 0.18725f
C606 a_21324_41600.n165 VSS 0.09255f
C607 a_21324_41600.n166 VSS 0.09921f
C608 a_21324_41600.n167 VSS 0.09921f
C609 a_21324_41600.n168 VSS 0.09921f
C610 a_21324_41600.n169 VSS 0.09921f
C611 a_21324_41600.n170 VSS 0.09921f
C612 a_21324_41600.n171 VSS 0.09921f
C613 a_21324_41600.n172 VSS 0.09921f
C614 a_21324_41600.n173 VSS 0.09921f
C615 a_21324_41600.n174 VSS 0.09921f
C616 a_21324_41600.n175 VSS 0.09921f
C617 a_21324_41600.n176 VSS 0.09921f
C618 a_21324_41600.n177 VSS 0.09921f
C619 a_21324_41600.n178 VSS 0.09921f
C620 a_21324_41600.n179 VSS 0.09921f
C621 a_21324_41600.n180 VSS 0.09921f
C622 a_21324_41600.n181 VSS 0.09921f
C623 a_21324_41600.n182 VSS 0.09921f
C624 a_21324_41600.n183 VSS 0.09921f
C625 a_21324_41600.n184 VSS 0.09921f
C626 a_21324_41600.n185 VSS 0.09921f
C627 a_21324_41600.n186 VSS 0.09921f
C628 a_21324_41600.n187 VSS 0.09921f
C629 a_21324_41600.n188 VSS 0.09921f
C630 a_21324_41600.n189 VSS 0.09921f
C631 a_21324_41600.n190 VSS 0.09921f
C632 a_21324_41600.n191 VSS 0.09921f
C633 a_21324_41600.n192 VSS 0.09921f
C634 a_21324_41600.n193 VSS 0.09921f
C635 a_21324_41600.n194 VSS 0.09921f
C636 a_21324_41600.n195 VSS 0.09921f
C637 a_21324_41600.n196 VSS 0.09921f
C638 a_21324_41600.n197 VSS 0.06433f
C639 a_21324_41600.n198 VSS 0.09921f
C640 a_21324_41600.n199 VSS 0.06433f
C641 a_21324_41600.n200 VSS 0.09921f
C642 a_21324_41600.n201 VSS 0.06433f
C643 a_21324_41600.n202 VSS 0.09921f
C644 a_21324_41600.n203 VSS 0.06433f
C645 a_21324_41600.n204 VSS 0.09921f
C646 a_21324_41600.n205 VSS 0.06433f
C647 a_21324_41600.n206 VSS 0.09921f
C648 a_21324_41600.n207 VSS 0.06433f
C649 a_21324_41600.n208 VSS 0.09921f
C650 a_21324_41600.n209 VSS 0.06433f
C651 a_21324_41600.n210 VSS 0.09921f
C652 a_21324_41600.n211 VSS 0.09255f
C653 a_21324_41600.n212 VSS 0.18725f
C654 a_21324_41600.n213 VSS 0.09921f
C655 a_21324_41600.n214 VSS 0.09921f
C656 a_21324_41600.n215 VSS 0.09921f
C657 a_21324_41600.n216 VSS 0.06433f
C658 a_21324_41600.n217 VSS 0.06433f
C659 a_21324_41600.n218 VSS 0.06433f
C660 a_21324_41600.n219 VSS 0.09921f
C661 a_21324_41600.n220 VSS 0.09921f
C662 a_21324_41600.n221 VSS 0.09921f
C663 a_21324_41600.n222 VSS 0.06433f
C664 a_21324_41600.n223 VSS 0.06433f
C665 a_21324_41600.n224 VSS 0.06433f
C666 a_21324_41600.n225 VSS 0.09921f
C667 a_21324_41600.n226 VSS 0.09921f
C668 a_21324_41600.n227 VSS 0.09921f
C669 a_21324_41600.n228 VSS 0.06433f
C670 a_21324_41600.n229 VSS 0.06433f
C671 a_21324_41600.n230 VSS 0.06433f
C672 a_21324_41600.n231 VSS 0.09921f
C673 a_21324_41600.n232 VSS 0.09921f
C674 a_21324_41600.n233 VSS 0.09921f
C675 a_21324_41600.n234 VSS 0.06433f
C676 a_21324_41600.n235 VSS 0.06433f
C677 a_21324_41600.n236 VSS 0.06433f
C678 a_21324_41600.n237 VSS 0.09921f
C679 a_21324_41600.n238 VSS 0.09921f
C680 a_21324_41600.n239 VSS 0.09921f
C681 a_21324_41600.n240 VSS 0.06433f
C682 a_21324_41600.n241 VSS 0.06433f
C683 a_21324_41600.n242 VSS 0.06433f
C684 a_21324_41600.n243 VSS 0.09921f
C685 a_21324_41600.n244 VSS 0.09921f
C686 a_21324_41600.n245 VSS 0.09921f
C687 a_21324_41600.n246 VSS 0.06433f
C688 a_21324_41600.n247 VSS 0.06433f
C689 a_21324_41600.n248 VSS 0.06433f
C690 a_21324_41600.n249 VSS 0.09921f
C691 a_21324_41600.n250 VSS 0.09921f
C692 a_21324_41600.n251 VSS 0.09921f
C693 a_21324_41600.n252 VSS 0.06433f
C694 a_21324_41600.n253 VSS 0.06433f
C695 a_21324_41600.n254 VSS 0.06433f
C696 a_21324_41600.n255 VSS 0.09921f
C697 a_21324_41600.n256 VSS 0.09921f
C698 a_21324_41600.n257 VSS 0.09921f
C699 a_21324_41600.n258 VSS 0.0542f
C700 a_21324_41600.n259 VSS 1.6892f
C701 a_21324_41600.n260 VSS 5.10393f
C702 a_21324_41600.t59 VSS 0.81752f
C703 a_21324_41600.t55 VSS 0.20776f
C704 a_21324_41600.t56 VSS 0.20776f
C705 a_21324_41600.n261 VSS 0.58203f
C706 a_21324_41600.n262 VSS 0.32802f
C707 a_21324_41600.t49 VSS 0.20776f
C708 a_21324_41600.t50 VSS 0.20776f
C709 a_21324_41600.n263 VSS 0.58203f
C710 a_21324_41600.n264 VSS 0.17257f
C711 a_21324_41600.t62 VSS 0.20776f
C712 a_21324_41600.t63 VSS 0.20776f
C713 a_21324_41600.n265 VSS 0.58203f
C714 a_21324_41600.n266 VSS 0.17257f
C715 a_21324_41600.t10 VSS 0.20776f
C716 a_21324_41600.t11 VSS 0.20776f
C717 a_21324_41600.n267 VSS 0.58203f
C718 a_21324_41600.n268 VSS 0.17257f
C719 a_21324_41600.t4 VSS 0.20776f
C720 a_21324_41600.t5 VSS 0.20776f
C721 a_21324_41600.n269 VSS 0.58203f
C722 a_21324_41600.n270 VSS 0.17257f
C723 a_21324_41600.t40 VSS 0.20776f
C724 a_21324_41600.t41 VSS 0.20776f
C725 a_21324_41600.n271 VSS 0.58203f
C726 a_21324_41600.n272 VSS 0.17257f
C727 a_21324_41600.t13 VSS 0.20776f
C728 a_21324_41600.t14 VSS 0.20776f
C729 a_21324_41600.n273 VSS 0.58203f
C730 a_21324_41600.n274 VSS 0.17257f
C731 a_21324_41600.t23 VSS 0.20776f
C732 a_21324_41600.t24 VSS 0.20776f
C733 a_21324_41600.n275 VSS 0.58203f
C734 a_21324_41600.n276 VSS 0.17257f
C735 a_21324_41600.t45 VSS 0.20776f
C736 a_21324_41600.t46 VSS 0.20776f
C737 a_21324_41600.n277 VSS 0.58203f
C738 a_21324_41600.n278 VSS 0.17257f
C739 a_21324_41600.t33 VSS 0.20776f
C740 a_21324_41600.t34 VSS 0.20776f
C741 a_21324_41600.n279 VSS 0.58203f
C742 a_21324_41600.n280 VSS 0.17257f
C743 a_21324_41600.t28 VSS 0.20776f
C744 a_21324_41600.t29 VSS 0.20776f
C745 a_21324_41600.n281 VSS 0.58203f
C746 a_21324_41600.n282 VSS 0.17257f
C747 a_21324_41600.t26 VSS 0.20776f
C748 a_21324_41600.t3 VSS 0.20776f
C749 a_21324_41600.n283 VSS 0.58203f
C750 a_21324_41600.n284 VSS 0.17257f
C751 a_21324_41600.t58 VSS 0.20776f
C752 a_21324_41600.t25 VSS 0.20776f
C753 a_21324_41600.n285 VSS 0.58203f
C754 a_21324_41600.n286 VSS 0.17257f
C755 a_21324_41600.t47 VSS 0.20776f
C756 a_21324_41600.t57 VSS 0.20776f
C757 a_21324_41600.n287 VSS 0.58203f
C758 a_21324_41600.n288 VSS 0.17257f
C759 a_21324_41600.t37 VSS 0.20776f
C760 a_21324_41600.t35 VSS 0.20776f
C761 a_21324_41600.n289 VSS 0.58203f
C762 a_21324_41600.n290 VSS 0.17257f
C763 a_21324_41600.t27 VSS 0.81225f
C764 a_21324_41600.n291 VSS 0.23603f
C765 a_21324_41600.n292 VSS 2.37976f
C766 a_21324_41600.t54 VSS 0.81366f
C767 a_21324_41600.n293 VSS 0.3481f
C768 a_21324_41600.t8 VSS 0.20776f
C769 a_21324_41600.t16 VSS 0.20776f
C770 a_21324_41600.n294 VSS 0.58635f
C771 a_21324_41600.n295 VSS 0.16825f
C772 a_21324_41600.t1 VSS 0.20776f
C773 a_21324_41600.t6 VSS 0.20776f
C774 a_21324_41600.n296 VSS 0.58635f
C775 a_21324_41600.n297 VSS 0.16825f
C776 a_21324_41600.t60 VSS 0.20776f
C777 a_21324_41600.t2 VSS 0.20776f
C778 a_21324_41600.n298 VSS 0.58635f
C779 a_21324_41600.n299 VSS 0.16825f
C780 a_21324_41600.t22 VSS 0.20776f
C781 a_21324_41600.t19 VSS 0.20776f
C782 a_21324_41600.n300 VSS 0.58635f
C783 a_21324_41600.n301 VSS 0.16825f
C784 a_21324_41600.t21 VSS 0.20776f
C785 a_21324_41600.t7 VSS 0.20776f
C786 a_21324_41600.n302 VSS 0.58635f
C787 a_21324_41600.n303 VSS 0.16825f
C788 a_21324_41600.t18 VSS 0.20776f
C789 a_21324_41600.t52 VSS 0.20776f
C790 a_21324_41600.n304 VSS 0.58635f
C791 a_21324_41600.n305 VSS 0.16825f
C792 a_21324_41600.t31 VSS 0.20776f
C793 a_21324_41600.t51 VSS 0.20776f
C794 a_21324_41600.n306 VSS 0.58635f
C795 a_21324_41600.n307 VSS 0.16825f
C796 a_21324_41600.t20 VSS 0.20776f
C797 a_21324_41600.t32 VSS 0.20776f
C798 a_21324_41600.n308 VSS 0.58635f
C799 a_21324_41600.n309 VSS 0.16825f
C800 a_21324_41600.t15 VSS 0.20776f
C801 a_21324_41600.t38 VSS 0.20776f
C802 a_21324_41600.n310 VSS 0.58635f
C803 a_21324_41600.n311 VSS 0.16825f
C804 a_21324_41600.n312 VSS 0.16825f
C805 a_21324_41600.n313 VSS 0.58635f
C806 a_21324_41600.t0 VSS 0.20776f
C807 a_2700_6400.t7 VSS 0.78987f
C808 a_2700_6400.t6 VSS 0.18411f
C809 a_2700_6400.t5 VSS 0.18411f
C810 a_2700_6400.n0 VSS 0.58157f
C811 a_2700_6400.n1 VSS 0.31967f
C812 a_2700_6400.t4 VSS 0.78465f
C813 a_2700_6400.n2 VSS 0.34526f
C814 a_2700_6400.n3 VSS 0.05376f
C815 a_2700_6400.n4 VSS 0.18572f
C816 a_2700_6400.n5 VSS 0.0918f
C817 a_2700_6400.n6 VSS 0.0984f
C818 a_2700_6400.n7 VSS 0.0984f
C819 a_2700_6400.n8 VSS 0.0984f
C820 a_2700_6400.n9 VSS 0.0918f
C821 a_2700_6400.n10 VSS 0.18572f
C822 a_2700_6400.n11 VSS 0.0984f
C823 a_2700_6400.n12 VSS 0.0984f
C824 a_2700_6400.n13 VSS 0.0984f
C825 a_2700_6400.n14 VSS 0.05376f
C826 a_2700_6400.n15 VSS 0.30181f
C827 a_2700_6400.n16 VSS 0.05376f
C828 a_2700_6400.n17 VSS 0.18572f
C829 a_2700_6400.n18 VSS 0.0918f
C830 a_2700_6400.n19 VSS 0.0984f
C831 a_2700_6400.n20 VSS 0.0984f
C832 a_2700_6400.n21 VSS 0.0984f
C833 a_2700_6400.n22 VSS 0.0918f
C834 a_2700_6400.n23 VSS 0.18572f
C835 a_2700_6400.n24 VSS 0.0984f
C836 a_2700_6400.n25 VSS 0.0984f
C837 a_2700_6400.n26 VSS 0.0984f
C838 a_2700_6400.n27 VSS 0.05376f
C839 a_2700_6400.n28 VSS 0.22605f
C840 a_2700_6400.n29 VSS 2.02655f
C841 a_2700_6400.n30 VSS 1.88452f
C842 a_2700_6400.t0 VSS 0.78326f
C843 a_2700_6400.n31 VSS 0.23411f
C844 a_2700_6400.t2 VSS 0.18411f
C845 a_2700_6400.t1 VSS 0.18411f
C846 a_2700_6400.n32 VSS 0.57729f
C847 a_2700_6400.n33 VSS 0.32535f
C848 a_2700_6400.t3 VSS 0.78848f
C849 a_4812_6400.t7 VSS 0.80734f
C850 a_4812_6400.t6 VSS 0.1763f
C851 a_4812_6400.t5 VSS 0.1763f
C852 a_4812_6400.n0 VSS 0.60614f
C853 a_4812_6400.n1 VSS 0.33317f
C854 a_4812_6400.t4 VSS 0.8019f
C855 a_4812_6400.n2 VSS 0.35985f
C856 a_4812_6400.n3 VSS 0.05603f
C857 a_4812_6400.n4 VSS 0.19357f
C858 a_4812_6400.n5 VSS 0.09568f
C859 a_4812_6400.n6 VSS 0.10256f
C860 a_4812_6400.n7 VSS 0.10256f
C861 a_4812_6400.n8 VSS 0.10256f
C862 a_4812_6400.n9 VSS 0.09568f
C863 a_4812_6400.n10 VSS 0.19357f
C864 a_4812_6400.n11 VSS 0.10256f
C865 a_4812_6400.n12 VSS 0.10256f
C866 a_4812_6400.n13 VSS 0.10256f
C867 a_4812_6400.n14 VSS 0.05603f
C868 a_4812_6400.n15 VSS 0.29102f
C869 a_4812_6400.n16 VSS 0.05603f
C870 a_4812_6400.n17 VSS 0.19357f
C871 a_4812_6400.n18 VSS 0.09568f
C872 a_4812_6400.n19 VSS 0.10256f
C873 a_4812_6400.n20 VSS 0.10256f
C874 a_4812_6400.n21 VSS 0.10256f
C875 a_4812_6400.n22 VSS 0.09568f
C876 a_4812_6400.n23 VSS 0.19357f
C877 a_4812_6400.n24 VSS 0.10256f
C878 a_4812_6400.n25 VSS 0.10256f
C879 a_4812_6400.n26 VSS 0.10256f
C880 a_4812_6400.n27 VSS 0.05603f
C881 a_4812_6400.n28 VSS 0.24849f
C882 a_4812_6400.n29 VSS 2.18227f
C883 a_4812_6400.n30 VSS 1.93796f
C884 a_4812_6400.t0 VSS 0.80045f
C885 a_4812_6400.n31 VSS 0.244f
C886 a_4812_6400.t2 VSS 0.1763f
C887 a_4812_6400.t1 VSS 0.1763f
C888 a_4812_6400.n32 VSS 0.60167f
C889 a_4812_6400.n33 VSS 0.33909f
C890 a_4812_6400.t3 VSS 0.8059f
C891 a_6924_6400.t7 VSS 0.80593f
C892 a_6924_6400.t6 VSS 0.18663f
C893 a_6924_6400.t5 VSS 0.18663f
C894 a_6924_6400.n0 VSS 0.5946f
C895 a_6924_6400.n1 VSS 0.32684f
C896 a_6924_6400.t4 VSS 0.80059f
C897 a_6924_6400.n2 VSS 0.353f
C898 a_6924_6400.n3 VSS 0.05497f
C899 a_6924_6400.n4 VSS 0.18988f
C900 a_6924_6400.n5 VSS 0.09386f
C901 a_6924_6400.n6 VSS 0.10061f
C902 a_6924_6400.n7 VSS 0.10061f
C903 a_6924_6400.n8 VSS 0.10061f
C904 a_6924_6400.n9 VSS 0.09386f
C905 a_6924_6400.n10 VSS 0.18988f
C906 a_6924_6400.n11 VSS 0.10061f
C907 a_6924_6400.n12 VSS 0.10061f
C908 a_6924_6400.n13 VSS 0.10061f
C909 a_6924_6400.n14 VSS 0.05497f
C910 a_6924_6400.n15 VSS 0.2652f
C911 a_6924_6400.n16 VSS 0.05497f
C912 a_6924_6400.n17 VSS 0.18988f
C913 a_6924_6400.n18 VSS 0.09386f
C914 a_6924_6400.n19 VSS 0.10061f
C915 a_6924_6400.n20 VSS 0.10061f
C916 a_6924_6400.n21 VSS 0.10061f
C917 a_6924_6400.n22 VSS 0.09386f
C918 a_6924_6400.n23 VSS 0.18988f
C919 a_6924_6400.n24 VSS 0.10061f
C920 a_6924_6400.n25 VSS 0.10061f
C921 a_6924_6400.n26 VSS 0.10061f
C922 a_6924_6400.n27 VSS 0.05497f
C923 a_6924_6400.n28 VSS 0.25997f
C924 a_6924_6400.n29 VSS 2.20328f
C925 a_6924_6400.n30 VSS 1.87531f
C926 a_6924_6400.t0 VSS 0.79917f
C927 a_6924_6400.n31 VSS 0.23936f
C928 a_6924_6400.t2 VSS 0.18663f
C929 a_6924_6400.t1 VSS 0.18663f
C930 a_6924_6400.n32 VSS 0.59022f
C931 a_6924_6400.n33 VSS 0.33264f
C932 a_6924_6400.t3 VSS 0.80451f
C933 a_14540_6400.t1 VSS 0.2088f
C934 a_14540_6400.t7 VSS 0.8086f
C935 a_14540_6400.n0 VSS 0.05319f
C936 a_14540_6400.n1 VSS 0.06313f
C937 a_14540_6400.n2 VSS 0.06313f
C938 a_14540_6400.n3 VSS 0.06313f
C939 a_14540_6400.n4 VSS 0.06313f
C940 a_14540_6400.n5 VSS 0.18374f
C941 a_14540_6400.n6 VSS 0.09082f
C942 a_14540_6400.n7 VSS 0.09735f
C943 a_14540_6400.n8 VSS 0.09735f
C944 a_14540_6400.n9 VSS 0.09735f
C945 a_14540_6400.n10 VSS 0.09735f
C946 a_14540_6400.n11 VSS 0.09735f
C947 a_14540_6400.n12 VSS 0.09735f
C948 a_14540_6400.n13 VSS 0.09735f
C949 a_14540_6400.n14 VSS 0.06313f
C950 a_14540_6400.n15 VSS 0.09735f
C951 a_14540_6400.n16 VSS 0.09082f
C952 a_14540_6400.n17 VSS 0.18374f
C953 a_14540_6400.n18 VSS 0.09735f
C954 a_14540_6400.n19 VSS 0.09735f
C955 a_14540_6400.n20 VSS 0.09735f
C956 a_14540_6400.n21 VSS 0.06313f
C957 a_14540_6400.n22 VSS 0.06313f
C958 a_14540_6400.n23 VSS 0.06313f
C959 a_14540_6400.n24 VSS 0.09735f
C960 a_14540_6400.n25 VSS 0.09735f
C961 a_14540_6400.n26 VSS 0.09735f
C962 a_14540_6400.n27 VSS 0.05319f
C963 a_14540_6400.n28 VSS 0.52036f
C964 a_14540_6400.n29 VSS 0.05319f
C965 a_14540_6400.n30 VSS 0.06313f
C966 a_14540_6400.n31 VSS 0.06313f
C967 a_14540_6400.n32 VSS 0.06313f
C968 a_14540_6400.n33 VSS 0.06313f
C969 a_14540_6400.n34 VSS 0.18374f
C970 a_14540_6400.n35 VSS 0.09082f
C971 a_14540_6400.n36 VSS 0.09735f
C972 a_14540_6400.n37 VSS 0.09735f
C973 a_14540_6400.n38 VSS 0.09735f
C974 a_14540_6400.n39 VSS 0.09735f
C975 a_14540_6400.n40 VSS 0.09735f
C976 a_14540_6400.n41 VSS 0.09735f
C977 a_14540_6400.n42 VSS 0.09735f
C978 a_14540_6400.n43 VSS 0.06313f
C979 a_14540_6400.n44 VSS 0.09735f
C980 a_14540_6400.n45 VSS 0.09082f
C981 a_14540_6400.n46 VSS 0.18374f
C982 a_14540_6400.n47 VSS 0.09735f
C983 a_14540_6400.n48 VSS 0.09735f
C984 a_14540_6400.n49 VSS 0.09735f
C985 a_14540_6400.n50 VSS 0.06313f
C986 a_14540_6400.n51 VSS 0.06313f
C987 a_14540_6400.n52 VSS 0.06313f
C988 a_14540_6400.n53 VSS 0.09735f
C989 a_14540_6400.n54 VSS 0.09735f
C990 a_14540_6400.n55 VSS 0.09735f
C991 a_14540_6400.n56 VSS 0.05319f
C992 a_14540_6400.n57 VSS 0.42016f
C993 a_14540_6400.n58 VSS 1.97824f
C994 a_14540_6400.t11 VSS 0.80723f
C995 a_14540_6400.t12 VSS 0.2088f
C996 a_14540_6400.t13 VSS 0.2088f
C997 a_14540_6400.n59 VSS 0.57112f
C998 a_14540_6400.n60 VSS 0.32187f
C999 a_14540_6400.t14 VSS 0.2088f
C1000 a_14540_6400.t15 VSS 0.2088f
C1001 a_14540_6400.n61 VSS 0.57112f
C1002 a_14540_6400.n62 VSS 0.16934f
C1003 a_14540_6400.t9 VSS 0.2088f
C1004 a_14540_6400.t10 VSS 0.2088f
C1005 a_14540_6400.n63 VSS 0.57112f
C1006 a_14540_6400.n64 VSS 0.16934f
C1007 a_14540_6400.t6 VSS 0.80206f
C1008 a_14540_6400.n65 VSS 0.23161f
C1009 a_14540_6400.n66 VSS 1.51516f
C1010 a_14540_6400.t8 VSS 0.80344f
C1011 a_14540_6400.n67 VSS 0.34157f
C1012 a_14540_6400.t4 VSS 0.2088f
C1013 a_14540_6400.t5 VSS 0.2088f
C1014 a_14540_6400.n68 VSS 0.57536f
C1015 a_14540_6400.n69 VSS 0.16509f
C1016 a_14540_6400.t2 VSS 0.2088f
C1017 a_14540_6400.t3 VSS 0.2088f
C1018 a_14540_6400.n70 VSS 0.57536f
C1019 a_14540_6400.n71 VSS 0.16509f
C1020 a_14540_6400.n72 VSS 0.31626f
C1021 a_14540_6400.n73 VSS 0.57536f
C1022 a_14540_6400.t0 VSS 0.2088f
C1023 a_17292_6400.t1 VSS 0.20563f
C1024 a_17292_6400.t12 VSS 0.80396f
C1025 a_17292_6400.t13 VSS 0.20563f
C1026 a_17292_6400.t14 VSS 0.20563f
C1027 a_17292_6400.n0 VSS 0.57108f
C1028 a_17292_6400.n1 VSS 0.32185f
C1029 a_17292_6400.t17 VSS 0.20563f
C1030 a_17292_6400.t18 VSS 0.20563f
C1031 a_17292_6400.n2 VSS 0.57108f
C1032 a_17292_6400.n3 VSS 0.16932f
C1033 a_17292_6400.t19 VSS 0.20563f
C1034 a_17292_6400.t3 VSS 0.20563f
C1035 a_17292_6400.n4 VSS 0.57108f
C1036 a_17292_6400.n5 VSS 0.16932f
C1037 a_17292_6400.t4 VSS 0.20563f
C1038 a_17292_6400.t5 VSS 0.20563f
C1039 a_17292_6400.n6 VSS 0.57108f
C1040 a_17292_6400.n7 VSS 0.16932f
C1041 a_17292_6400.t30 VSS 0.80533f
C1042 a_17292_6400.t31 VSS 0.20563f
C1043 a_17292_6400.t8 VSS 0.20563f
C1044 a_17292_6400.n8 VSS 0.57532f
C1045 a_17292_6400.n9 VSS 0.31624f
C1046 a_17292_6400.t9 VSS 0.20563f
C1047 a_17292_6400.t22 VSS 0.20563f
C1048 a_17292_6400.n10 VSS 0.57532f
C1049 a_17292_6400.n11 VSS 0.16508f
C1050 a_17292_6400.t23 VSS 0.20563f
C1051 a_17292_6400.t20 VSS 0.20563f
C1052 a_17292_6400.n12 VSS 0.57532f
C1053 a_17292_6400.n13 VSS 0.16508f
C1054 a_17292_6400.t21 VSS 0.20563f
C1055 a_17292_6400.t10 VSS 0.20563f
C1056 a_17292_6400.n14 VSS 0.57532f
C1057 a_17292_6400.n15 VSS 0.16508f
C1058 a_17292_6400.t11 VSS 0.20563f
C1059 a_17292_6400.t27 VSS 0.20563f
C1060 a_17292_6400.n16 VSS 0.57532f
C1061 a_17292_6400.n17 VSS 0.16508f
C1062 a_17292_6400.t28 VSS 0.20563f
C1063 a_17292_6400.t6 VSS 0.20563f
C1064 a_17292_6400.n18 VSS 0.57532f
C1065 a_17292_6400.n19 VSS 0.16508f
C1066 a_17292_6400.t7 VSS 0.20563f
C1067 a_17292_6400.t15 VSS 0.20563f
C1068 a_17292_6400.n20 VSS 0.57532f
C1069 a_17292_6400.n21 VSS 0.16508f
C1070 a_17292_6400.t16 VSS 0.80017f
C1071 a_17292_6400.n22 VSS 0.34155f
C1072 a_17292_6400.n23 VSS 0.05318f
C1073 a_17292_6400.n24 VSS 0.06312f
C1074 a_17292_6400.n25 VSS 0.06312f
C1075 a_17292_6400.n26 VSS 0.06312f
C1076 a_17292_6400.n27 VSS 0.06312f
C1077 a_17292_6400.n28 VSS 0.06312f
C1078 a_17292_6400.n29 VSS 0.06312f
C1079 a_17292_6400.n30 VSS 0.06312f
C1080 a_17292_6400.n31 VSS 0.06312f
C1081 a_17292_6400.n32 VSS 0.06312f
C1082 a_17292_6400.n33 VSS 0.06312f
C1083 a_17292_6400.n34 VSS 0.06312f
C1084 a_17292_6400.n35 VSS 0.06312f
C1085 a_17292_6400.n36 VSS 0.18373f
C1086 a_17292_6400.n37 VSS 0.09081f
C1087 a_17292_6400.n38 VSS 0.09734f
C1088 a_17292_6400.n39 VSS 0.09734f
C1089 a_17292_6400.n40 VSS 0.09734f
C1090 a_17292_6400.n41 VSS 0.09734f
C1091 a_17292_6400.n42 VSS 0.09734f
C1092 a_17292_6400.n43 VSS 0.09734f
C1093 a_17292_6400.n44 VSS 0.09734f
C1094 a_17292_6400.n45 VSS 0.09734f
C1095 a_17292_6400.n46 VSS 0.09734f
C1096 a_17292_6400.n47 VSS 0.09734f
C1097 a_17292_6400.n48 VSS 0.09734f
C1098 a_17292_6400.n49 VSS 0.09734f
C1099 a_17292_6400.n50 VSS 0.09734f
C1100 a_17292_6400.n51 VSS 0.09734f
C1101 a_17292_6400.n52 VSS 0.09734f
C1102 a_17292_6400.n53 VSS 0.06312f
C1103 a_17292_6400.n54 VSS 0.09734f
C1104 a_17292_6400.n55 VSS 0.06312f
C1105 a_17292_6400.n56 VSS 0.09734f
C1106 a_17292_6400.n57 VSS 0.06312f
C1107 a_17292_6400.n58 VSS 0.09734f
C1108 a_17292_6400.n59 VSS 0.09081f
C1109 a_17292_6400.n60 VSS 0.18373f
C1110 a_17292_6400.n61 VSS 0.09734f
C1111 a_17292_6400.n62 VSS 0.09734f
C1112 a_17292_6400.n63 VSS 0.09734f
C1113 a_17292_6400.n64 VSS 0.06312f
C1114 a_17292_6400.n65 VSS 0.06312f
C1115 a_17292_6400.n66 VSS 0.06312f
C1116 a_17292_6400.n67 VSS 0.09734f
C1117 a_17292_6400.n68 VSS 0.09734f
C1118 a_17292_6400.n69 VSS 0.09734f
C1119 a_17292_6400.n70 VSS 0.06312f
C1120 a_17292_6400.n71 VSS 0.06312f
C1121 a_17292_6400.n72 VSS 0.06312f
C1122 a_17292_6400.n73 VSS 0.09734f
C1123 a_17292_6400.n74 VSS 0.09734f
C1124 a_17292_6400.n75 VSS 0.09734f
C1125 a_17292_6400.n76 VSS 0.06312f
C1126 a_17292_6400.n77 VSS 0.06312f
C1127 a_17292_6400.n78 VSS 0.06312f
C1128 a_17292_6400.n79 VSS 0.09734f
C1129 a_17292_6400.n80 VSS 0.09734f
C1130 a_17292_6400.n81 VSS 0.09734f
C1131 a_17292_6400.n82 VSS 0.05318f
C1132 a_17292_6400.n83 VSS 0.99199f
C1133 a_17292_6400.n84 VSS 0.05318f
C1134 a_17292_6400.n85 VSS 0.06312f
C1135 a_17292_6400.n86 VSS 0.06312f
C1136 a_17292_6400.n87 VSS 0.06312f
C1137 a_17292_6400.n88 VSS 0.06312f
C1138 a_17292_6400.n89 VSS 0.06312f
C1139 a_17292_6400.n90 VSS 0.06312f
C1140 a_17292_6400.n91 VSS 0.06312f
C1141 a_17292_6400.n92 VSS 0.06312f
C1142 a_17292_6400.n93 VSS 0.06312f
C1143 a_17292_6400.n94 VSS 0.06312f
C1144 a_17292_6400.n95 VSS 0.06312f
C1145 a_17292_6400.n96 VSS 0.06312f
C1146 a_17292_6400.n97 VSS 0.18373f
C1147 a_17292_6400.n98 VSS 0.09081f
C1148 a_17292_6400.n99 VSS 0.09734f
C1149 a_17292_6400.n100 VSS 0.09734f
C1150 a_17292_6400.n101 VSS 0.09734f
C1151 a_17292_6400.n102 VSS 0.09734f
C1152 a_17292_6400.n103 VSS 0.09734f
C1153 a_17292_6400.n104 VSS 0.09734f
C1154 a_17292_6400.n105 VSS 0.09734f
C1155 a_17292_6400.n106 VSS 0.09734f
C1156 a_17292_6400.n107 VSS 0.09734f
C1157 a_17292_6400.n108 VSS 0.09734f
C1158 a_17292_6400.n109 VSS 0.09734f
C1159 a_17292_6400.n110 VSS 0.09734f
C1160 a_17292_6400.n111 VSS 0.09734f
C1161 a_17292_6400.n112 VSS 0.09734f
C1162 a_17292_6400.n113 VSS 0.09734f
C1163 a_17292_6400.n114 VSS 0.06312f
C1164 a_17292_6400.n115 VSS 0.09734f
C1165 a_17292_6400.n116 VSS 0.06312f
C1166 a_17292_6400.n117 VSS 0.09734f
C1167 a_17292_6400.n118 VSS 0.06312f
C1168 a_17292_6400.n119 VSS 0.09734f
C1169 a_17292_6400.n120 VSS 0.09081f
C1170 a_17292_6400.n121 VSS 0.18373f
C1171 a_17292_6400.n122 VSS 0.09734f
C1172 a_17292_6400.n123 VSS 0.09734f
C1173 a_17292_6400.n124 VSS 0.09734f
C1174 a_17292_6400.n125 VSS 0.06312f
C1175 a_17292_6400.n126 VSS 0.06312f
C1176 a_17292_6400.n127 VSS 0.06312f
C1177 a_17292_6400.n128 VSS 0.09734f
C1178 a_17292_6400.n129 VSS 0.09734f
C1179 a_17292_6400.n130 VSS 0.09734f
C1180 a_17292_6400.n131 VSS 0.06312f
C1181 a_17292_6400.n132 VSS 0.06312f
C1182 a_17292_6400.n133 VSS 0.06312f
C1183 a_17292_6400.n134 VSS 0.09734f
C1184 a_17292_6400.n135 VSS 0.09734f
C1185 a_17292_6400.n136 VSS 0.09734f
C1186 a_17292_6400.n137 VSS 0.06312f
C1187 a_17292_6400.n138 VSS 0.06312f
C1188 a_17292_6400.n139 VSS 0.06312f
C1189 a_17292_6400.n140 VSS 0.09734f
C1190 a_17292_6400.n141 VSS 0.09734f
C1191 a_17292_6400.n142 VSS 0.09734f
C1192 a_17292_6400.n143 VSS 0.05318f
C1193 a_17292_6400.n144 VSS 0.79175f
C1194 a_17292_6400.n145 VSS 3.04808f
C1195 a_17292_6400.n146 VSS 1.92476f
C1196 a_17292_6400.t29 VSS 0.79879f
C1197 a_17292_6400.n147 VSS 0.23159f
C1198 a_17292_6400.t25 VSS 0.20563f
C1199 a_17292_6400.t26 VSS 0.20563f
C1200 a_17292_6400.n148 VSS 0.57108f
C1201 a_17292_6400.n149 VSS 0.16932f
C1202 a_17292_6400.t2 VSS 0.20563f
C1203 a_17292_6400.t24 VSS 0.20563f
C1204 a_17292_6400.n150 VSS 0.57108f
C1205 a_17292_6400.n151 VSS 0.16932f
C1206 a_17292_6400.n152 VSS 0.16932f
C1207 a_17292_6400.n153 VSS 0.57108f
C1208 a_17292_6400.t0 VSS 0.20563f
C1209 a_21324_6400.t6 VSS 0.20776f
C1210 a_21324_6400.t52 VSS 0.81752f
C1211 a_21324_6400.t53 VSS 0.20776f
C1212 a_21324_6400.t44 VSS 0.20776f
C1213 a_21324_6400.n0 VSS 0.58203f
C1214 a_21324_6400.n1 VSS 0.32802f
C1215 a_21324_6400.t45 VSS 0.20776f
C1216 a_21324_6400.t46 VSS 0.20776f
C1217 a_21324_6400.n2 VSS 0.58203f
C1218 a_21324_6400.n3 VSS 0.17257f
C1219 a_21324_6400.t47 VSS 0.20776f
C1220 a_21324_6400.t40 VSS 0.20776f
C1221 a_21324_6400.n4 VSS 0.58203f
C1222 a_21324_6400.n5 VSS 0.17257f
C1223 a_21324_6400.t41 VSS 0.20776f
C1224 a_21324_6400.t42 VSS 0.20776f
C1225 a_21324_6400.n6 VSS 0.58203f
C1226 a_21324_6400.n7 VSS 0.17257f
C1227 a_21324_6400.t43 VSS 0.20776f
C1228 a_21324_6400.t48 VSS 0.20776f
C1229 a_21324_6400.n8 VSS 0.58203f
C1230 a_21324_6400.n9 VSS 0.17257f
C1231 a_21324_6400.t49 VSS 0.20776f
C1232 a_21324_6400.t50 VSS 0.20776f
C1233 a_21324_6400.n10 VSS 0.58203f
C1234 a_21324_6400.n11 VSS 0.17257f
C1235 a_21324_6400.t51 VSS 0.20776f
C1236 a_21324_6400.t7 VSS 0.20776f
C1237 a_21324_6400.n12 VSS 0.58203f
C1238 a_21324_6400.n13 VSS 0.17257f
C1239 a_21324_6400.t8 VSS 0.20776f
C1240 a_21324_6400.t9 VSS 0.20776f
C1241 a_21324_6400.n14 VSS 0.58203f
C1242 a_21324_6400.n15 VSS 0.17257f
C1243 a_21324_6400.t10 VSS 0.20776f
C1244 a_21324_6400.t3 VSS 0.20776f
C1245 a_21324_6400.n16 VSS 0.58203f
C1246 a_21324_6400.n17 VSS 0.17257f
C1247 a_21324_6400.t4 VSS 0.20776f
C1248 a_21324_6400.t5 VSS 0.20776f
C1249 a_21324_6400.n18 VSS 0.58203f
C1250 a_21324_6400.n19 VSS 0.17257f
C1251 a_21324_6400.t62 VSS 0.81892f
C1252 a_21324_6400.t63 VSS 0.20776f
C1253 a_21324_6400.t25 VSS 0.20776f
C1254 a_21324_6400.n20 VSS 0.58635f
C1255 a_21324_6400.n21 VSS 0.3223f
C1256 a_21324_6400.t26 VSS 0.20776f
C1257 a_21324_6400.t27 VSS 0.20776f
C1258 a_21324_6400.n22 VSS 0.58635f
C1259 a_21324_6400.n23 VSS 0.16825f
C1260 a_21324_6400.t22 VSS 0.20776f
C1261 a_21324_6400.t23 VSS 0.20776f
C1262 a_21324_6400.n24 VSS 0.58635f
C1263 a_21324_6400.n25 VSS 0.16825f
C1264 a_21324_6400.t24 VSS 0.20776f
C1265 a_21324_6400.t19 VSS 0.20776f
C1266 a_21324_6400.n26 VSS 0.58635f
C1267 a_21324_6400.n27 VSS 0.16825f
C1268 a_21324_6400.t20 VSS 0.20776f
C1269 a_21324_6400.t21 VSS 0.20776f
C1270 a_21324_6400.n28 VSS 0.58635f
C1271 a_21324_6400.n29 VSS 0.16825f
C1272 a_21324_6400.t38 VSS 0.20776f
C1273 a_21324_6400.t39 VSS 0.20776f
C1274 a_21324_6400.n30 VSS 0.58635f
C1275 a_21324_6400.n31 VSS 0.16825f
C1276 a_21324_6400.t36 VSS 0.20776f
C1277 a_21324_6400.t37 VSS 0.20776f
C1278 a_21324_6400.n32 VSS 0.58635f
C1279 a_21324_6400.n33 VSS 0.16825f
C1280 a_21324_6400.t17 VSS 0.20776f
C1281 a_21324_6400.t18 VSS 0.20776f
C1282 a_21324_6400.n34 VSS 0.58635f
C1283 a_21324_6400.n35 VSS 0.16825f
C1284 a_21324_6400.t13 VSS 0.20776f
C1285 a_21324_6400.t14 VSS 0.20776f
C1286 a_21324_6400.n36 VSS 0.58635f
C1287 a_21324_6400.n37 VSS 0.16825f
C1288 a_21324_6400.t15 VSS 0.20776f
C1289 a_21324_6400.t16 VSS 0.20776f
C1290 a_21324_6400.n38 VSS 0.58635f
C1291 a_21324_6400.n39 VSS 0.16825f
C1292 a_21324_6400.t11 VSS 0.20776f
C1293 a_21324_6400.t12 VSS 0.20776f
C1294 a_21324_6400.n40 VSS 0.58635f
C1295 a_21324_6400.n41 VSS 0.16825f
C1296 a_21324_6400.t54 VSS 0.20776f
C1297 a_21324_6400.t55 VSS 0.20776f
C1298 a_21324_6400.n42 VSS 0.58635f
C1299 a_21324_6400.n43 VSS 0.16825f
C1300 a_21324_6400.t59 VSS 0.20776f
C1301 a_21324_6400.t60 VSS 0.20776f
C1302 a_21324_6400.n44 VSS 0.58635f
C1303 a_21324_6400.n45 VSS 0.16825f
C1304 a_21324_6400.t34 VSS 0.20776f
C1305 a_21324_6400.t35 VSS 0.20776f
C1306 a_21324_6400.n46 VSS 0.58635f
C1307 a_21324_6400.n47 VSS 0.16825f
C1308 a_21324_6400.t32 VSS 0.20776f
C1309 a_21324_6400.t33 VSS 0.20776f
C1310 a_21324_6400.n48 VSS 0.58635f
C1311 a_21324_6400.n49 VSS 0.16825f
C1312 a_21324_6400.t31 VSS 0.81366f
C1313 a_21324_6400.n50 VSS 0.3481f
C1314 a_21324_6400.n51 VSS 0.0542f
C1315 a_21324_6400.n52 VSS 0.06433f
C1316 a_21324_6400.n53 VSS 0.06433f
C1317 a_21324_6400.n54 VSS 0.06433f
C1318 a_21324_6400.n55 VSS 0.06433f
C1319 a_21324_6400.n56 VSS 0.06433f
C1320 a_21324_6400.n57 VSS 0.06433f
C1321 a_21324_6400.n58 VSS 0.06433f
C1322 a_21324_6400.n59 VSS 0.06433f
C1323 a_21324_6400.n60 VSS 0.06433f
C1324 a_21324_6400.n61 VSS 0.06433f
C1325 a_21324_6400.n62 VSS 0.06433f
C1326 a_21324_6400.n63 VSS 0.06433f
C1327 a_21324_6400.n64 VSS 0.06433f
C1328 a_21324_6400.n65 VSS 0.06433f
C1329 a_21324_6400.n66 VSS 0.06433f
C1330 a_21324_6400.n67 VSS 0.06433f
C1331 a_21324_6400.n68 VSS 0.06433f
C1332 a_21324_6400.n69 VSS 0.06433f
C1333 a_21324_6400.n70 VSS 0.06433f
C1334 a_21324_6400.n71 VSS 0.06433f
C1335 a_21324_6400.n72 VSS 0.06433f
C1336 a_21324_6400.n73 VSS 0.06433f
C1337 a_21324_6400.n74 VSS 0.06433f
C1338 a_21324_6400.n75 VSS 0.06433f
C1339 a_21324_6400.n76 VSS 0.06433f
C1340 a_21324_6400.n77 VSS 0.06433f
C1341 a_21324_6400.n78 VSS 0.06433f
C1342 a_21324_6400.n79 VSS 0.06433f
C1343 a_21324_6400.n80 VSS 0.18725f
C1344 a_21324_6400.n81 VSS 0.09255f
C1345 a_21324_6400.n82 VSS 0.09921f
C1346 a_21324_6400.n83 VSS 0.09921f
C1347 a_21324_6400.n84 VSS 0.09921f
C1348 a_21324_6400.n85 VSS 0.09921f
C1349 a_21324_6400.n86 VSS 0.09921f
C1350 a_21324_6400.n87 VSS 0.09921f
C1351 a_21324_6400.n88 VSS 0.09921f
C1352 a_21324_6400.n89 VSS 0.09921f
C1353 a_21324_6400.n90 VSS 0.09921f
C1354 a_21324_6400.n91 VSS 0.09921f
C1355 a_21324_6400.n92 VSS 0.09921f
C1356 a_21324_6400.n93 VSS 0.09921f
C1357 a_21324_6400.n94 VSS 0.09921f
C1358 a_21324_6400.n95 VSS 0.09921f
C1359 a_21324_6400.n96 VSS 0.09921f
C1360 a_21324_6400.n97 VSS 0.09921f
C1361 a_21324_6400.n98 VSS 0.09921f
C1362 a_21324_6400.n99 VSS 0.09921f
C1363 a_21324_6400.n100 VSS 0.09921f
C1364 a_21324_6400.n101 VSS 0.09921f
C1365 a_21324_6400.n102 VSS 0.09921f
C1366 a_21324_6400.n103 VSS 0.09921f
C1367 a_21324_6400.n104 VSS 0.09921f
C1368 a_21324_6400.n105 VSS 0.09921f
C1369 a_21324_6400.n106 VSS 0.09921f
C1370 a_21324_6400.n107 VSS 0.09921f
C1371 a_21324_6400.n108 VSS 0.09921f
C1372 a_21324_6400.n109 VSS 0.09921f
C1373 a_21324_6400.n110 VSS 0.09921f
C1374 a_21324_6400.n111 VSS 0.09921f
C1375 a_21324_6400.n112 VSS 0.09921f
C1376 a_21324_6400.n113 VSS 0.06433f
C1377 a_21324_6400.n114 VSS 0.09921f
C1378 a_21324_6400.n115 VSS 0.06433f
C1379 a_21324_6400.n116 VSS 0.09921f
C1380 a_21324_6400.n117 VSS 0.06433f
C1381 a_21324_6400.n118 VSS 0.09921f
C1382 a_21324_6400.n119 VSS 0.06433f
C1383 a_21324_6400.n120 VSS 0.09921f
C1384 a_21324_6400.n121 VSS 0.06433f
C1385 a_21324_6400.n122 VSS 0.09921f
C1386 a_21324_6400.n123 VSS 0.06433f
C1387 a_21324_6400.n124 VSS 0.09921f
C1388 a_21324_6400.n125 VSS 0.06433f
C1389 a_21324_6400.n126 VSS 0.09921f
C1390 a_21324_6400.n127 VSS 0.09255f
C1391 a_21324_6400.n128 VSS 0.18725f
C1392 a_21324_6400.n129 VSS 0.09921f
C1393 a_21324_6400.n130 VSS 0.09921f
C1394 a_21324_6400.n131 VSS 0.09921f
C1395 a_21324_6400.n132 VSS 0.06433f
C1396 a_21324_6400.n133 VSS 0.06433f
C1397 a_21324_6400.n134 VSS 0.06433f
C1398 a_21324_6400.n135 VSS 0.09921f
C1399 a_21324_6400.n136 VSS 0.09921f
C1400 a_21324_6400.n137 VSS 0.09921f
C1401 a_21324_6400.n138 VSS 0.06433f
C1402 a_21324_6400.n139 VSS 0.06433f
C1403 a_21324_6400.n140 VSS 0.06433f
C1404 a_21324_6400.n141 VSS 0.09921f
C1405 a_21324_6400.n142 VSS 0.09921f
C1406 a_21324_6400.n143 VSS 0.09921f
C1407 a_21324_6400.n144 VSS 0.06433f
C1408 a_21324_6400.n145 VSS 0.06433f
C1409 a_21324_6400.n146 VSS 0.06433f
C1410 a_21324_6400.n147 VSS 0.09921f
C1411 a_21324_6400.n148 VSS 0.09921f
C1412 a_21324_6400.n149 VSS 0.09921f
C1413 a_21324_6400.n150 VSS 0.06433f
C1414 a_21324_6400.n151 VSS 0.06433f
C1415 a_21324_6400.n152 VSS 0.06433f
C1416 a_21324_6400.n153 VSS 0.09921f
C1417 a_21324_6400.n154 VSS 0.09921f
C1418 a_21324_6400.n155 VSS 0.09921f
C1419 a_21324_6400.n156 VSS 0.06433f
C1420 a_21324_6400.n157 VSS 0.06433f
C1421 a_21324_6400.n158 VSS 0.06433f
C1422 a_21324_6400.n159 VSS 0.09921f
C1423 a_21324_6400.n160 VSS 0.09921f
C1424 a_21324_6400.n161 VSS 0.09921f
C1425 a_21324_6400.n162 VSS 0.06433f
C1426 a_21324_6400.n163 VSS 0.06433f
C1427 a_21324_6400.n164 VSS 0.06433f
C1428 a_21324_6400.n165 VSS 0.09921f
C1429 a_21324_6400.n166 VSS 0.09921f
C1430 a_21324_6400.n167 VSS 0.09921f
C1431 a_21324_6400.n168 VSS 0.06433f
C1432 a_21324_6400.n169 VSS 0.06433f
C1433 a_21324_6400.n170 VSS 0.06433f
C1434 a_21324_6400.n171 VSS 0.09921f
C1435 a_21324_6400.n172 VSS 0.09921f
C1436 a_21324_6400.n173 VSS 0.09921f
C1437 a_21324_6400.n174 VSS 0.0542f
C1438 a_21324_6400.n175 VSS 1.82602f
C1439 a_21324_6400.n176 VSS 0.0542f
C1440 a_21324_6400.n177 VSS 0.06433f
C1441 a_21324_6400.n178 VSS 0.06433f
C1442 a_21324_6400.n179 VSS 0.06433f
C1443 a_21324_6400.n180 VSS 0.06433f
C1444 a_21324_6400.n181 VSS 0.06433f
C1445 a_21324_6400.n182 VSS 0.06433f
C1446 a_21324_6400.n183 VSS 0.06433f
C1447 a_21324_6400.n184 VSS 0.06433f
C1448 a_21324_6400.n185 VSS 0.06433f
C1449 a_21324_6400.n186 VSS 0.06433f
C1450 a_21324_6400.n187 VSS 0.06433f
C1451 a_21324_6400.n188 VSS 0.06433f
C1452 a_21324_6400.n189 VSS 0.06433f
C1453 a_21324_6400.n190 VSS 0.06433f
C1454 a_21324_6400.n191 VSS 0.06433f
C1455 a_21324_6400.n192 VSS 0.06433f
C1456 a_21324_6400.n193 VSS 0.06433f
C1457 a_21324_6400.n194 VSS 0.06433f
C1458 a_21324_6400.n195 VSS 0.06433f
C1459 a_21324_6400.n196 VSS 0.06433f
C1460 a_21324_6400.n197 VSS 0.06433f
C1461 a_21324_6400.n198 VSS 0.06433f
C1462 a_21324_6400.n199 VSS 0.06433f
C1463 a_21324_6400.n200 VSS 0.06433f
C1464 a_21324_6400.n201 VSS 0.06433f
C1465 a_21324_6400.n202 VSS 0.06433f
C1466 a_21324_6400.n203 VSS 0.06433f
C1467 a_21324_6400.n204 VSS 0.06433f
C1468 a_21324_6400.n205 VSS 0.18725f
C1469 a_21324_6400.n206 VSS 0.09255f
C1470 a_21324_6400.n207 VSS 0.09921f
C1471 a_21324_6400.n208 VSS 0.09921f
C1472 a_21324_6400.n209 VSS 0.09921f
C1473 a_21324_6400.n210 VSS 0.09921f
C1474 a_21324_6400.n211 VSS 0.09921f
C1475 a_21324_6400.n212 VSS 0.09921f
C1476 a_21324_6400.n213 VSS 0.09921f
C1477 a_21324_6400.n214 VSS 0.09921f
C1478 a_21324_6400.n215 VSS 0.09921f
C1479 a_21324_6400.n216 VSS 0.09921f
C1480 a_21324_6400.n217 VSS 0.09921f
C1481 a_21324_6400.n218 VSS 0.09921f
C1482 a_21324_6400.n219 VSS 0.09921f
C1483 a_21324_6400.n220 VSS 0.09921f
C1484 a_21324_6400.n221 VSS 0.09921f
C1485 a_21324_6400.n222 VSS 0.09921f
C1486 a_21324_6400.n223 VSS 0.09921f
C1487 a_21324_6400.n224 VSS 0.09921f
C1488 a_21324_6400.n225 VSS 0.09921f
C1489 a_21324_6400.n226 VSS 0.09921f
C1490 a_21324_6400.n227 VSS 0.09921f
C1491 a_21324_6400.n228 VSS 0.09921f
C1492 a_21324_6400.n229 VSS 0.09921f
C1493 a_21324_6400.n230 VSS 0.09921f
C1494 a_21324_6400.n231 VSS 0.09921f
C1495 a_21324_6400.n232 VSS 0.09921f
C1496 a_21324_6400.n233 VSS 0.09921f
C1497 a_21324_6400.n234 VSS 0.09921f
C1498 a_21324_6400.n235 VSS 0.09921f
C1499 a_21324_6400.n236 VSS 0.09921f
C1500 a_21324_6400.n237 VSS 0.09921f
C1501 a_21324_6400.n238 VSS 0.06433f
C1502 a_21324_6400.n239 VSS 0.09921f
C1503 a_21324_6400.n240 VSS 0.06433f
C1504 a_21324_6400.n241 VSS 0.09921f
C1505 a_21324_6400.n242 VSS 0.06433f
C1506 a_21324_6400.n243 VSS 0.09921f
C1507 a_21324_6400.n244 VSS 0.06433f
C1508 a_21324_6400.n245 VSS 0.09921f
C1509 a_21324_6400.n246 VSS 0.06433f
C1510 a_21324_6400.n247 VSS 0.09921f
C1511 a_21324_6400.n248 VSS 0.06433f
C1512 a_21324_6400.n249 VSS 0.09921f
C1513 a_21324_6400.n250 VSS 0.06433f
C1514 a_21324_6400.n251 VSS 0.09921f
C1515 a_21324_6400.n252 VSS 0.09255f
C1516 a_21324_6400.n253 VSS 0.18725f
C1517 a_21324_6400.n254 VSS 0.09921f
C1518 a_21324_6400.n255 VSS 0.09921f
C1519 a_21324_6400.n256 VSS 0.09921f
C1520 a_21324_6400.n257 VSS 0.06433f
C1521 a_21324_6400.n258 VSS 0.06433f
C1522 a_21324_6400.n259 VSS 0.06433f
C1523 a_21324_6400.n260 VSS 0.09921f
C1524 a_21324_6400.n261 VSS 0.09921f
C1525 a_21324_6400.n262 VSS 0.09921f
C1526 a_21324_6400.n263 VSS 0.06433f
C1527 a_21324_6400.n264 VSS 0.06433f
C1528 a_21324_6400.n265 VSS 0.06433f
C1529 a_21324_6400.n266 VSS 0.09921f
C1530 a_21324_6400.n267 VSS 0.09921f
C1531 a_21324_6400.n268 VSS 0.09921f
C1532 a_21324_6400.n269 VSS 0.06433f
C1533 a_21324_6400.n270 VSS 0.06433f
C1534 a_21324_6400.n271 VSS 0.06433f
C1535 a_21324_6400.n272 VSS 0.09921f
C1536 a_21324_6400.n273 VSS 0.09921f
C1537 a_21324_6400.n274 VSS 0.09921f
C1538 a_21324_6400.n275 VSS 0.06433f
C1539 a_21324_6400.n276 VSS 0.06433f
C1540 a_21324_6400.n277 VSS 0.06433f
C1541 a_21324_6400.n278 VSS 0.09921f
C1542 a_21324_6400.n279 VSS 0.09921f
C1543 a_21324_6400.n280 VSS 0.09921f
C1544 a_21324_6400.n281 VSS 0.06433f
C1545 a_21324_6400.n282 VSS 0.06433f
C1546 a_21324_6400.n283 VSS 0.06433f
C1547 a_21324_6400.n284 VSS 0.09921f
C1548 a_21324_6400.n285 VSS 0.09921f
C1549 a_21324_6400.n286 VSS 0.09921f
C1550 a_21324_6400.n287 VSS 0.06433f
C1551 a_21324_6400.n288 VSS 0.06433f
C1552 a_21324_6400.n289 VSS 0.06433f
C1553 a_21324_6400.n290 VSS 0.09921f
C1554 a_21324_6400.n291 VSS 0.09921f
C1555 a_21324_6400.n292 VSS 0.09921f
C1556 a_21324_6400.n293 VSS 0.06433f
C1557 a_21324_6400.n294 VSS 0.06433f
C1558 a_21324_6400.n295 VSS 0.06433f
C1559 a_21324_6400.n296 VSS 0.09921f
C1560 a_21324_6400.n297 VSS 0.09921f
C1561 a_21324_6400.n298 VSS 0.09921f
C1562 a_21324_6400.n299 VSS 0.0542f
C1563 a_21324_6400.n300 VSS 1.6892f
C1564 a_21324_6400.n301 VSS 5.10393f
C1565 a_21324_6400.n302 VSS 2.37976f
C1566 a_21324_6400.t61 VSS 0.81225f
C1567 a_21324_6400.n303 VSS 0.23603f
C1568 a_21324_6400.t57 VSS 0.20776f
C1569 a_21324_6400.t58 VSS 0.20776f
C1570 a_21324_6400.n304 VSS 0.58203f
C1571 a_21324_6400.n305 VSS 0.17257f
C1572 a_21324_6400.t30 VSS 0.20776f
C1573 a_21324_6400.t56 VSS 0.20776f
C1574 a_21324_6400.n306 VSS 0.58203f
C1575 a_21324_6400.n307 VSS 0.17257f
C1576 a_21324_6400.t28 VSS 0.20776f
C1577 a_21324_6400.t29 VSS 0.20776f
C1578 a_21324_6400.n308 VSS 0.58203f
C1579 a_21324_6400.n309 VSS 0.17257f
C1580 a_21324_6400.t1 VSS 0.20776f
C1581 a_21324_6400.t2 VSS 0.20776f
C1582 a_21324_6400.n310 VSS 0.58203f
C1583 a_21324_6400.n311 VSS 0.17257f
C1584 a_21324_6400.n312 VSS 0.17257f
C1585 a_21324_6400.n313 VSS 0.58203f
C1586 a_21324_6400.t0 VSS 0.20776f
C1587 VSS.t395 VSS 0.09629f
C1588 VSS.t389 VSS 0.09814f
C1589 VSS.t391 VSS 0.09629f
C1590 VSS.t393 VSS 0.09629f
C1591 VSS.t513 VSS 0.09629f
C1592 VSS.t515 VSS 0.09629f
C1593 VSS.t401 VSS 0.09629f
C1594 VSS.t511 VSS 0.09629f
C1595 VSS.t397 VSS 0.09629f
C1596 VSS.t399 VSS 0.09629f
C1597 VSS.t405 VSS 0.09629f
C1598 VSS.t407 VSS 0.09629f
C1599 VSS.t413 VSS 0.09629f
C1600 VSS.t403 VSS 0.09629f
C1601 VSS.t409 VSS 0.09629f
C1602 VSS.t411 VSS 0.09629f
C1603 VSS.t417 VSS 0.09629f
C1604 VSS.t419 VSS 0.09629f
C1605 VSS.t425 VSS 0.09629f
C1606 VSS.t415 VSS 0.09629f
C1607 VSS.t421 VSS 0.09629f
C1608 VSS.t423 VSS 0.09629f
C1609 VSS.t429 VSS 0.09629f
C1610 VSS.t431 VSS 0.09629f
C1611 VSS.t437 VSS 0.09629f
C1612 VSS.t427 VSS 0.09629f
C1613 VSS.t433 VSS 0.09629f
C1614 VSS.t435 VSS 0.09629f
C1615 VSS.t441 VSS 0.09629f
C1616 VSS.t443 VSS 0.09629f
C1617 VSS.t449 VSS 0.09629f
C1618 VSS.t439 VSS 0.09629f
C1619 VSS.t445 VSS 0.09629f
C1620 VSS.t447 VSS 0.09629f
C1621 VSS.t453 VSS 0.09629f
C1622 VSS.t455 VSS 0.09629f
C1623 VSS.t461 VSS 0.09629f
C1624 VSS.t451 VSS 0.09629f
C1625 VSS.t457 VSS 0.09629f
C1626 VSS.t459 VSS 0.09629f
C1627 VSS.t465 VSS 0.09629f
C1628 VSS.t467 VSS 0.09629f
C1629 VSS.t473 VSS 0.09629f
C1630 VSS.t463 VSS 0.09629f
C1631 VSS.t469 VSS 0.09629f
C1632 VSS.t471 VSS 0.09629f
C1633 VSS.t477 VSS 0.09629f
C1634 VSS.t479 VSS 0.09629f
C1635 VSS.t485 VSS 0.09629f
C1636 VSS.t475 VSS 0.09629f
C1637 VSS.t481 VSS 0.09629f
C1638 VSS.t483 VSS 0.09629f
C1639 VSS.t489 VSS 0.09629f
C1640 VSS.t491 VSS 0.09629f
C1641 VSS.t497 VSS 0.09629f
C1642 VSS.t487 VSS 0.09629f
C1643 VSS.t493 VSS 0.09629f
C1644 VSS.t495 VSS 0.09629f
C1645 VSS.t501 VSS 0.09629f
C1646 VSS.t503 VSS 0.09629f
C1647 VSS.t509 VSS 0.09629f
C1648 VSS.t499 VSS 0.09629f
C1649 VSS.t505 VSS 0.09814f
C1650 VSS.t507 VSS 0.09629f
C1651 VSS.t559 VSS 0.09448f
C1652 VSS.t567 VSS 0.09629f
C1653 VSS.t555 VSS 0.09448f
C1654 VSS.t557 VSS 0.09448f
C1655 VSS.t361 VSS 0.09448f
C1656 VSS.t363 VSS 0.09448f
C1657 VSS.t219 VSS 0.09448f
C1658 VSS.t359 VSS 0.09448f
C1659 VSS.t215 VSS 0.09448f
C1660 VSS.t217 VSS 0.09448f
C1661 VSS.t225 VSS 0.09448f
C1662 VSS.t227 VSS 0.09448f
C1663 VSS.t221 VSS 0.09448f
C1664 VSS.t223 VSS 0.09448f
C1665 VSS.t233 VSS 0.09448f
C1666 VSS.t235 VSS 0.09448f
C1667 VSS.t229 VSS 0.09448f
C1668 VSS.t231 VSS 0.09448f
C1669 VSS.t385 VSS 0.09448f
C1670 VSS.t387 VSS 0.09448f
C1671 VSS.t381 VSS 0.09448f
C1672 VSS.t383 VSS 0.09448f
C1673 VSS.t369 VSS 0.09448f
C1674 VSS.t371 VSS 0.09448f
C1675 VSS.t365 VSS 0.09448f
C1676 VSS.t367 VSS 0.09448f
C1677 VSS.t377 VSS 0.09448f
C1678 VSS.t379 VSS 0.09448f
C1679 VSS.t373 VSS 0.09448f
C1680 VSS.t375 VSS 0.09448f
C1681 VSS.t517 VSS 0.09629f
C1682 VSS.t519 VSS 0.09448f
C1683 VSS.t549 VSS 0.09449f
C1684 VSS.t587 VSS 0.0963f
C1685 VSS.t545 VSS 0.09449f
C1686 VSS.t547 VSS 0.09449f
C1687 VSS.t31 VSS 0.09449f
C1688 VSS.t33 VSS 0.09449f
C1689 VSS.t81 VSS 0.09449f
C1690 VSS.t29 VSS 0.09449f
C1691 VSS.t77 VSS 0.09449f
C1692 VSS.t79 VSS 0.09449f
C1693 VSS.t311 VSS 0.09449f
C1694 VSS.t313 VSS 0.09449f
C1695 VSS.t153 VSS 0.09449f
C1696 VSS.t309 VSS 0.09449f
C1697 VSS.t149 VSS 0.0963f
C1698 VSS.t151 VSS 0.09449f
C1699 VSS.t563 VSS 0.09765f
C1700 VSS.t357 VSS 0.09952f
C1701 VSS.t575 VSS 0.09765f
C1702 VSS.t561 VSS 0.09765f
C1703 VSS.t571 VSS 0.09765f
C1704 VSS.t573 VSS 0.09765f
C1705 VSS.t565 VSS 0.09952f
C1706 VSS.t569 VSS 0.09765f
C1707 VSS.t167 VSS 0.09954f
C1708 VSS.t577 VSS 0.10145f
C1709 VSS.t75 VSS 0.09954f
C1710 VSS.t1 VSS 0.09954f
C1711 VSS.t209 VSS 0.09954f
C1712 VSS.t169 VSS 0.09954f
C1713 VSS.t579 VSS 0.10145f
C1714 VSS.t581 VSS 0.09954f
C1715 VSS.t295 VSS 0.09551f
C1716 VSS.t59 VSS 0.09734f
C1717 VSS.t323 VSS 0.09551f
C1718 VSS.t35 VSS 0.09551f
C1719 VSS.t551 VSS 0.09551f
C1720 VSS.t585 VSS 0.09551f
C1721 VSS.t157 VSS 0.09734f
C1722 VSS.t155 VSS 0.09551f
C1723 VSS.t325 VSS 0.07176f
C1724 VSS.t327 VSS 0.07313f
C1725 VSS.t339 VSS 0.07313f
C1726 VSS.t337 VSS 0.07176f
C1727 VSS.t275 VSS 0.0592f
C1728 VSS.t273 VSS 0.06033f
C1729 VSS.t279 VSS 0.06033f
C1730 VSS.t277 VSS 0.0592f
C1731 VSS.t329 VSS 0.07176f
C1732 VSS.t333 VSS 0.07313f
C1733 VSS.t335 VSS 0.07313f
C1734 VSS.t331 VSS 0.07176f
C1735 VSS.t63 VSS 0.09629f
C1736 VSS.t135 VSS 0.09814f
C1737 VSS.t5 VSS 0.09629f
C1738 VSS.t61 VSS 0.09629f
C1739 VSS.t123 VSS 0.09629f
C1740 VSS.t3 VSS 0.09629f
C1741 VSS.t139 VSS 0.09629f
C1742 VSS.t121 VSS 0.09629f
C1743 VSS.t67 VSS 0.09629f
C1744 VSS.t137 VSS 0.09629f
C1745 VSS.t9 VSS 0.09629f
C1746 VSS.t65 VSS 0.09629f
C1747 VSS.t127 VSS 0.09629f
C1748 VSS.t7 VSS 0.09629f
C1749 VSS.t143 VSS 0.09629f
C1750 VSS.t125 VSS 0.09629f
C1751 VSS.t71 VSS 0.09629f
C1752 VSS.t141 VSS 0.09629f
C1753 VSS.t13 VSS 0.09629f
C1754 VSS.t69 VSS 0.09629f
C1755 VSS.t523 VSS 0.09629f
C1756 VSS.t11 VSS 0.09629f
C1757 VSS.t39 VSS 0.09629f
C1758 VSS.t521 VSS 0.09629f
C1759 VSS.t85 VSS 0.09629f
C1760 VSS.t37 VSS 0.09629f
C1761 VSS.t177 VSS 0.09629f
C1762 VSS.t83 VSS 0.09629f
C1763 VSS.t239 VSS 0.09629f
C1764 VSS.t175 VSS 0.09629f
C1765 VSS.t283 VSS 0.09629f
C1766 VSS.t237 VSS 0.09629f
C1767 VSS.t43 VSS 0.09629f
C1768 VSS.t281 VSS 0.09629f
C1769 VSS.t89 VSS 0.09629f
C1770 VSS.t41 VSS 0.09629f
C1771 VSS.t181 VSS 0.09629f
C1772 VSS.t87 VSS 0.09629f
C1773 VSS.t299 VSS 0.09629f
C1774 VSS.t179 VSS 0.09629f
C1775 VSS.t131 VSS 0.09629f
C1776 VSS.t297 VSS 0.09629f
C1777 VSS.t531 VSS 0.09629f
C1778 VSS.t129 VSS 0.09629f
C1779 VSS.t243 VSS 0.09629f
C1780 VSS.t529 VSS 0.09629f
C1781 VSS.t287 VSS 0.09629f
C1782 VSS.t241 VSS 0.09629f
C1783 VSS.t185 VSS 0.09629f
C1784 VSS.t285 VSS 0.09629f
C1785 VSS.t303 VSS 0.09629f
C1786 VSS.t183 VSS 0.09629f
C1787 VSS.t147 VSS 0.09629f
C1788 VSS.t301 VSS 0.09629f
C1789 VSS.t527 VSS 0.09629f
C1790 VSS.t145 VSS 0.09629f
C1791 VSS.t47 VSS 0.09629f
C1792 VSS.t525 VSS 0.09629f
C1793 VSS.t93 VSS 0.09629f
C1794 VSS.t45 VSS 0.09629f
C1795 VSS.t251 VSS 0.09629f
C1796 VSS.t91 VSS 0.09629f
C1797 VSS.t293 VSS 0.09814f
C1798 VSS.t249 VSS 0.09629f
C1799 VSS.t207 VSS 0.09448f
C1800 VSS.t103 VSS 0.09629f
C1801 VSS.t543 VSS 0.09448f
C1802 VSS.t211 VSS 0.09448f
C1803 VSS.t99 VSS 0.09448f
C1804 VSS.t319 VSS 0.09448f
C1805 VSS.t19 VSS 0.09448f
C1806 VSS.t553 VSS 0.09448f
C1807 VSS.t119 VSS 0.09448f
C1808 VSS.t101 VSS 0.09448f
C1809 VSS.t205 VSS 0.09448f
C1810 VSS.t117 VSS 0.09448f
C1811 VSS.t317 VSS 0.09448f
C1812 VSS.t203 VSS 0.09448f
C1813 VSS.t97 VSS 0.09448f
C1814 VSS.t315 VSS 0.09448f
C1815 VSS.t57 VSS 0.09448f
C1816 VSS.t95 VSS 0.09448f
C1817 VSS.t255 VSS 0.09448f
C1818 VSS.t55 VSS 0.09448f
C1819 VSS.t23 VSS 0.09448f
C1820 VSS.t253 VSS 0.09448f
C1821 VSS.t53 VSS 0.09448f
C1822 VSS.t21 VSS 0.09448f
C1823 VSS.t591 VSS 0.09448f
C1824 VSS.t51 VSS 0.09448f
C1825 VSS.t355 VSS 0.09448f
C1826 VSS.t589 VSS 0.09448f
C1827 VSS.t541 VSS 0.09448f
C1828 VSS.t353 VSS 0.09448f
C1829 VSS.t583 VSS 0.09629f
C1830 VSS.t539 VSS 0.09448f
C1831 VSS.t109 VSS 0.09449f
C1832 VSS.t111 VSS 0.0963f
C1833 VSS.t171 VSS 0.09449f
C1834 VSS.t173 VSS 0.09449f
C1835 VSS.t113 VSS 0.09449f
C1836 VSS.t115 VSS 0.09449f
C1837 VSS.t195 VSS 0.09449f
C1838 VSS.t197 VSS 0.09449f
C1839 VSS.t349 VSS 0.09449f
C1840 VSS.t351 VSS 0.09449f
C1841 VSS.t345 VSS 0.09449f
C1842 VSS.t347 VSS 0.09449f
C1843 VSS.t341 VSS 0.09449f
C1844 VSS.t343 VSS 0.09449f
C1845 VSS.t105 VSS 0.0963f
C1846 VSS.t107 VSS 0.09449f
C1847 VSS.t533 VSS 0.09765f
C1848 VSS.t535 VSS 0.09952f
C1849 VSS.t245 VSS 0.09765f
C1850 VSS.t247 VSS 0.09765f
C1851 VSS.t289 VSS 0.09765f
C1852 VSS.t291 VSS 0.09765f
C1853 VSS.t187 VSS 0.09952f
C1854 VSS.t189 VSS 0.09765f
C1855 VSS.t193 VSS 0.09954f
C1856 VSS.t49 VSS 0.10145f
C1857 VSS.t307 VSS 0.09954f
C1858 VSS.t191 VSS 0.09954f
C1859 VSS.t201 VSS 0.09954f
C1860 VSS.t305 VSS 0.09954f
C1861 VSS.t537 VSS 0.10145f
C1862 VSS.t199 VSS 0.09954f
C1863 VSS.t17 VSS 0.09551f
C1864 VSS.t73 VSS 0.09734f
C1865 VSS.t213 VSS 0.09551f
C1866 VSS.t15 VSS 0.09551f
C1867 VSS.t27 VSS 0.09551f
C1868 VSS.t25 VSS 0.09551f
C1869 VSS.t321 VSS 0.09734f
C1870 VSS.t133 VSS 0.09551f
C1871 VSS.t271 VSS 0.07037f
C1872 VSS.t259 VSS 0.07172f
C1873 VSS.t257 VSS 0.07172f
C1874 VSS.t267 VSS 0.07037f
C1875 VSS.t161 VSS 0.0592f
C1876 VSS.t159 VSS 0.06033f
C1877 VSS.t165 VSS 0.06033f
C1878 VSS.t163 VSS 0.0592f
C1879 VSS.t269 VSS 0.07037f
C1880 VSS.t261 VSS 0.07172f
C1881 VSS.t263 VSS 0.07172f
C1882 VSS.t265 VSS 0.07037f
C1883 VDD.n0 VSS 0.01087f
C1884 VDD.t486 VSS 3.30973f
C1885 VDD.t488 VSS 0.16067f
C1886 VDD.t480 VSS 0.16067f
C1887 VDD.t482 VSS 0.16067f
C1888 VDD.t484 VSS 0.16067f
C1889 VDD.t474 VSS 0.16067f
C1890 VDD.t476 VSS 0.16067f
C1891 VDD.t478 VSS 0.16067f
C1892 VDD.t430 VSS 0.16067f
C1893 VDD.t432 VSS 0.16067f
C1894 VDD.t434 VSS 0.16067f
C1895 VDD.t440 VSS 0.16067f
C1896 VDD.t442 VSS 0.16067f
C1897 VDD.t444 VSS 0.16067f
C1898 VDD.t422 VSS 0.16067f
C1899 VDD.t424 VSS 0.16067f
C1900 VDD.t414 VSS 0.16067f
C1901 VDD.t416 VSS 0.16067f
C1902 VDD.t406 VSS 0.16067f
C1903 VDD.t408 VSS 0.16067f
C1904 VDD.t410 VSS 0.16067f
C1905 VDD.t412 VSS 0.16067f
C1906 VDD.t402 VSS 0.16067f
C1907 VDD.t404 VSS 0.16067f
C1908 VDD.t378 VSS 0.16067f
C1909 VDD.t380 VSS 0.16067f
C1910 VDD.t352 VSS 0.16067f
C1911 VDD.t354 VSS 0.16067f
C1912 VDD.t322 VSS 0.16067f
C1913 VDD.t324 VSS 0.16067f
C1914 VDD.t306 VSS 0.16067f
C1915 VDD.t308 VSS 0.16067f
C1916 VDD.t314 VSS 0.16067f
C1917 VDD.t316 VSS 0.16067f
C1918 VDD.t298 VSS 0.16067f
C1919 VDD.t300 VSS 0.16067f
C1920 VDD.t540 VSS 0.16067f
C1921 VDD.t542 VSS 0.16067f
C1922 VDD.t382 VSS 0.16067f
C1923 VDD.t384 VSS 0.16067f
C1924 VDD.t426 VSS 0.16067f
C1925 VDD.t428 VSS 0.16067f
C1926 VDD.t418 VSS 0.16067f
C1927 VDD.t420 VSS 0.16067f
C1928 VDD.t436 VSS 0.16067f
C1929 VDD.t438 VSS 0.16067f
C1930 VDD.t470 VSS 0.16067f
C1931 VDD.t472 VSS 0.16067f
C1932 VDD.t466 VSS 0.16067f
C1933 VDD.t468 VSS 0.16067f
C1934 VDD.t462 VSS 0.16067f
C1935 VDD.t464 VSS 0.16067f
C1936 VDD.t348 VSS 0.16067f
C1937 VDD.t350 VSS 0.16067f
C1938 VDD.t374 VSS 0.16067f
C1939 VDD.t376 VSS 0.16067f
C1940 VDD.t458 VSS 0.16067f
C1941 VDD.t460 VSS 0.16067f
C1942 VDD.t454 VSS 0.16067f
C1943 VDD.t456 VSS 0.16067f
C1944 VDD.t450 VSS 0.16067f
C1945 VDD.t452 VSS 0.16067f
C1946 VDD.t446 VSS 0.16067f
C1947 VDD.t448 VSS 0.89973f
C1948 VDD.t558 VSS 0.89973f
C1949 VDD.t560 VSS 0.16067f
C1950 VDD.t342 VSS 0.16067f
C1951 VDD.t344 VSS 0.16067f
C1952 VDD.t346 VSS 0.16067f
C1953 VDD.t336 VSS 0.16067f
C1954 VDD.t338 VSS 0.16067f
C1955 VDD.t340 VSS 0.16067f
C1956 VDD.t330 VSS 0.16067f
C1957 VDD.t332 VSS 0.16067f
C1958 VDD.t334 VSS 0.16067f
C1959 VDD.t370 VSS 0.16067f
C1960 VDD.t372 VSS 0.16067f
C1961 VDD.t366 VSS 0.16067f
C1962 VDD.t368 VSS 0.16067f
C1963 VDD.t326 VSS 0.16067f
C1964 VDD.t328 VSS 0.16067f
C1965 VDD.t310 VSS 0.16067f
C1966 VDD.t312 VSS 0.16067f
C1967 VDD.t318 VSS 0.16067f
C1968 VDD.t320 VSS 0.16067f
C1969 VDD.t302 VSS 0.16067f
C1970 VDD.t304 VSS 0.16067f
C1971 VDD.t550 VSS 0.16067f
C1972 VDD.t552 VSS 0.16067f
C1973 VDD.t554 VSS 0.16067f
C1974 VDD.t556 VSS 0.16067f
C1975 VDD.t362 VSS 0.16067f
C1976 VDD.t364 VSS 0.16067f
C1977 VDD.t358 VSS 0.16067f
C1978 VDD.t360 VSS 0.16067f
C1979 VDD.t356 VSS 0.89973f
C1980 VDD.t588 VSS 0.89973f
C1981 VDD.t590 VSS 0.16067f
C1982 VDD.t124 VSS 0.16067f
C1983 VDD.t126 VSS 0.16067f
C1984 VDD.t524 VSS 0.16067f
C1985 VDD.t526 VSS 0.16067f
C1986 VDD.t254 VSS 0.16067f
C1987 VDD.t256 VSS 0.16067f
C1988 VDD.t152 VSS 0.16067f
C1989 VDD.t154 VSS 0.16067f
C1990 VDD.t576 VSS 0.16067f
C1991 VDD.t578 VSS 0.16067f
C1992 VDD.t110 VSS 0.16067f
C1993 VDD.t112 VSS 0.16067f
C1994 VDD.t242 VSS 0.16067f
C1995 VDD.t244 VSS 0.89973f
C1996 VDD.t296 VSS 0.89973f
C1997 VDD.t32 VSS 0.16067f
C1998 VDD.t34 VSS 0.16067f
C1999 VDD.t36 VSS 0.16067f
C2000 VDD.t38 VSS 0.16067f
C2001 VDD.t292 VSS 0.16067f
C2002 VDD.t294 VSS 0.16067f
C2003 VDD.t516 VSS 0.89973f
C2004 VDD.t40 VSS 0.89973f
C2005 VDD.t22 VSS 0.16067f
C2006 VDD.t518 VSS 0.16067f
C2007 VDD.t114 VSS 0.16067f
C2008 VDD.t122 VSS 0.16067f
C2009 VDD.t574 VSS 0.16067f
C2010 VDD.t0 VSS 0.16067f
C2011 VDD.t248 VSS 0.89973f
C2012 VDD.t128 VSS 0.89973f
C2013 VDD.t258 VSS 0.16067f
C2014 VDD.t206 VSS 0.16067f
C2015 VDD.t76 VSS 0.16067f
C2016 VDD.t246 VSS 0.16067f
C2017 VDD.t178 VSS 0.16067f
C2018 VDD.t580 VSS 0.16067f
C2019 VDD.t116 VSS 0.89973f
C2020 VDD.t266 VSS 0.89973f
C2021 VDD.t260 VSS 0.16067f
C2022 VDD.t274 VSS 0.16067f
C2023 VDD.t272 VSS 0.89973f
C2024 VDD.t230 VSS 0.89973f
C2025 VDD.t228 VSS 0.16067f
C2026 VDD.t226 VSS 0.16067f
C2027 VDD.t224 VSS 0.89973f
C2028 VDD.t268 VSS 0.89973f
C2029 VDD.t270 VSS 0.16067f
C2030 VDD.t264 VSS 0.16067f
C2031 VDD.t262 VSS 0.90052f
C2032 VDD.t447 VSS 0.10783f
C2033 VDD.t449 VSS 0.10968f
C2034 VDD.n1 VSS 0.0602f
C2035 VDD.t451 VSS 0.10783f
C2036 VDD.t453 VSS 0.10783f
C2037 VDD.n2 VSS 0.05973f
C2038 VDD.n3 VSS 0.03027f
C2039 VDD.t455 VSS 0.10783f
C2040 VDD.t457 VSS 0.10783f
C2041 VDD.n4 VSS 0.05973f
C2042 VDD.n5 VSS 0.01714f
C2043 VDD.t459 VSS 0.10783f
C2044 VDD.t461 VSS 0.10783f
C2045 VDD.n6 VSS 0.05973f
C2046 VDD.n7 VSS 0.01714f
C2047 VDD.t375 VSS 0.10783f
C2048 VDD.t377 VSS 0.10783f
C2049 VDD.n8 VSS 0.05973f
C2050 VDD.n9 VSS 0.01714f
C2051 VDD.t349 VSS 0.10783f
C2052 VDD.t351 VSS 0.10783f
C2053 VDD.n10 VSS 0.05973f
C2054 VDD.n11 VSS 0.01714f
C2055 VDD.t463 VSS 0.10783f
C2056 VDD.t465 VSS 0.10783f
C2057 VDD.n12 VSS 0.05973f
C2058 VDD.n13 VSS 0.01714f
C2059 VDD.t467 VSS 0.10783f
C2060 VDD.t469 VSS 0.10783f
C2061 VDD.n14 VSS 0.05973f
C2062 VDD.n15 VSS 0.01714f
C2063 VDD.t471 VSS 0.10783f
C2064 VDD.t473 VSS 0.10783f
C2065 VDD.n16 VSS 0.05973f
C2066 VDD.n17 VSS 0.01714f
C2067 VDD.t437 VSS 0.10783f
C2068 VDD.t439 VSS 0.10783f
C2069 VDD.n18 VSS 0.05973f
C2070 VDD.n19 VSS 0.01714f
C2071 VDD.t419 VSS 0.10783f
C2072 VDD.t421 VSS 0.10783f
C2073 VDD.n20 VSS 0.05973f
C2074 VDD.n21 VSS 0.01714f
C2075 VDD.t427 VSS 0.10783f
C2076 VDD.t429 VSS 0.10783f
C2077 VDD.n22 VSS 0.05973f
C2078 VDD.n23 VSS 0.01714f
C2079 VDD.t383 VSS 0.10783f
C2080 VDD.t385 VSS 0.10783f
C2081 VDD.n24 VSS 0.05973f
C2082 VDD.n25 VSS 0.01714f
C2083 VDD.t541 VSS 0.10783f
C2084 VDD.t543 VSS 0.10783f
C2085 VDD.n26 VSS 0.05973f
C2086 VDD.n27 VSS 0.01714f
C2087 VDD.t299 VSS 0.10783f
C2088 VDD.t301 VSS 0.10783f
C2089 VDD.n28 VSS 0.05973f
C2090 VDD.n29 VSS 0.01714f
C2091 VDD.t315 VSS 0.10783f
C2092 VDD.t317 VSS 0.10783f
C2093 VDD.n30 VSS 0.05973f
C2094 VDD.n31 VSS 0.01714f
C2095 VDD.t307 VSS 0.10783f
C2096 VDD.t309 VSS 0.10783f
C2097 VDD.n32 VSS 0.05973f
C2098 VDD.n33 VSS 0.01714f
C2099 VDD.t323 VSS 0.10783f
C2100 VDD.t325 VSS 0.10783f
C2101 VDD.n34 VSS 0.05973f
C2102 VDD.n35 VSS 0.01714f
C2103 VDD.t353 VSS 0.10783f
C2104 VDD.t355 VSS 0.10783f
C2105 VDD.n36 VSS 0.05973f
C2106 VDD.n37 VSS 0.01714f
C2107 VDD.t379 VSS 0.10783f
C2108 VDD.t381 VSS 0.10783f
C2109 VDD.n38 VSS 0.05973f
C2110 VDD.n39 VSS 0.01714f
C2111 VDD.t403 VSS 0.10783f
C2112 VDD.t405 VSS 0.10783f
C2113 VDD.n40 VSS 0.05973f
C2114 VDD.n41 VSS 0.01714f
C2115 VDD.t411 VSS 0.10783f
C2116 VDD.t413 VSS 0.10783f
C2117 VDD.n42 VSS 0.05973f
C2118 VDD.n43 VSS 0.01714f
C2119 VDD.t407 VSS 0.10783f
C2120 VDD.t409 VSS 0.10783f
C2121 VDD.n44 VSS 0.05973f
C2122 VDD.n45 VSS 0.01714f
C2123 VDD.t415 VSS 0.10783f
C2124 VDD.t417 VSS 0.10783f
C2125 VDD.n46 VSS 0.05973f
C2126 VDD.n47 VSS 0.01714f
C2127 VDD.t423 VSS 0.10783f
C2128 VDD.t425 VSS 0.10783f
C2129 VDD.n48 VSS 0.05973f
C2130 VDD.n49 VSS 0.01714f
C2131 VDD.t443 VSS 0.10783f
C2132 VDD.t445 VSS 0.10783f
C2133 VDD.n50 VSS 0.05973f
C2134 VDD.n51 VSS 0.01714f
C2135 VDD.t435 VSS 0.10783f
C2136 VDD.t441 VSS 0.10783f
C2137 VDD.n52 VSS 0.05973f
C2138 VDD.n53 VSS 0.01714f
C2139 VDD.t431 VSS 0.10783f
C2140 VDD.t433 VSS 0.10783f
C2141 VDD.n54 VSS 0.05973f
C2142 VDD.n55 VSS 0.01714f
C2143 VDD.t477 VSS 0.10783f
C2144 VDD.t479 VSS 0.10783f
C2145 VDD.n56 VSS 0.05973f
C2146 VDD.n57 VSS 0.01714f
C2147 VDD.t485 VSS 0.10783f
C2148 VDD.t475 VSS 0.10783f
C2149 VDD.n58 VSS 0.05973f
C2150 VDD.n59 VSS 0.01714f
C2151 VDD.t481 VSS 0.10783f
C2152 VDD.t483 VSS 0.10783f
C2153 VDD.n60 VSS 0.05973f
C2154 VDD.n61 VSS 0.01714f
C2155 VDD.t487 VSS 0.10968f
C2156 VDD.t489 VSS 0.10783f
C2157 VDD.n62 VSS 0.05973f
C2158 VDD.n63 VSS 0.21014f
C2159 VDD.t361 VSS 0.10602f
C2160 VDD.t357 VSS 0.10783f
C2161 VDD.n64 VSS 0.0602f
C2162 VDD.t365 VSS 0.10602f
C2163 VDD.t359 VSS 0.10602f
C2164 VDD.n65 VSS 0.05973f
C2165 VDD.n66 VSS 0.03027f
C2166 VDD.t557 VSS 0.10602f
C2167 VDD.t363 VSS 0.10602f
C2168 VDD.n67 VSS 0.05973f
C2169 VDD.n68 VSS 0.01714f
C2170 VDD.t553 VSS 0.10602f
C2171 VDD.t555 VSS 0.10602f
C2172 VDD.n69 VSS 0.05973f
C2173 VDD.n70 VSS 0.01714f
C2174 VDD.t305 VSS 0.10602f
C2175 VDD.t551 VSS 0.10602f
C2176 VDD.n71 VSS 0.05973f
C2177 VDD.n72 VSS 0.01714f
C2178 VDD.t321 VSS 0.10602f
C2179 VDD.t303 VSS 0.10602f
C2180 VDD.n73 VSS 0.05973f
C2181 VDD.n74 VSS 0.01714f
C2182 VDD.t313 VSS 0.10602f
C2183 VDD.t319 VSS 0.10602f
C2184 VDD.n75 VSS 0.05973f
C2185 VDD.n76 VSS 0.01714f
C2186 VDD.t329 VSS 0.10602f
C2187 VDD.t311 VSS 0.10602f
C2188 VDD.n77 VSS 0.05973f
C2189 VDD.n78 VSS 0.01714f
C2190 VDD.t369 VSS 0.10602f
C2191 VDD.t327 VSS 0.10602f
C2192 VDD.n79 VSS 0.05973f
C2193 VDD.n80 VSS 0.01714f
C2194 VDD.t373 VSS 0.10602f
C2195 VDD.t367 VSS 0.10602f
C2196 VDD.n81 VSS 0.05973f
C2197 VDD.n82 VSS 0.01714f
C2198 VDD.t335 VSS 0.10602f
C2199 VDD.t371 VSS 0.10602f
C2200 VDD.n83 VSS 0.05973f
C2201 VDD.n84 VSS 0.01714f
C2202 VDD.t331 VSS 0.10602f
C2203 VDD.t333 VSS 0.10602f
C2204 VDD.n85 VSS 0.05973f
C2205 VDD.n86 VSS 0.01714f
C2206 VDD.t339 VSS 0.10602f
C2207 VDD.t341 VSS 0.10602f
C2208 VDD.n87 VSS 0.05973f
C2209 VDD.n88 VSS 0.01714f
C2210 VDD.t347 VSS 0.10602f
C2211 VDD.t337 VSS 0.10602f
C2212 VDD.n89 VSS 0.05973f
C2213 VDD.n90 VSS 0.01714f
C2214 VDD.t343 VSS 0.10602f
C2215 VDD.t345 VSS 0.10602f
C2216 VDD.n91 VSS 0.05973f
C2217 VDD.n92 VSS 0.01714f
C2218 VDD.t559 VSS 0.10783f
C2219 VDD.t561 VSS 0.10602f
C2220 VDD.n93 VSS 0.05973f
C2221 VDD.n94 VSS 0.06691f
C2222 VDD.n95 VSS 3.28526f
C2223 VDD.t243 VSS 0.10603f
C2224 VDD.t245 VSS 0.10784f
C2225 VDD.n96 VSS 0.0602f
C2226 VDD.t111 VSS 0.10603f
C2227 VDD.t113 VSS 0.10603f
C2228 VDD.n97 VSS 0.05973f
C2229 VDD.n98 VSS 0.03027f
C2230 VDD.t577 VSS 0.10603f
C2231 VDD.t579 VSS 0.10603f
C2232 VDD.n99 VSS 0.05973f
C2233 VDD.n100 VSS 0.01714f
C2234 VDD.t153 VSS 0.10603f
C2235 VDD.t155 VSS 0.10603f
C2236 VDD.n101 VSS 0.05973f
C2237 VDD.n102 VSS 0.01714f
C2238 VDD.t255 VSS 0.10603f
C2239 VDD.t257 VSS 0.10603f
C2240 VDD.n103 VSS 0.05973f
C2241 VDD.n104 VSS 0.01714f
C2242 VDD.t525 VSS 0.10603f
C2243 VDD.t527 VSS 0.10603f
C2244 VDD.n105 VSS 0.05973f
C2245 VDD.n106 VSS 0.01714f
C2246 VDD.t125 VSS 0.10603f
C2247 VDD.t127 VSS 0.10603f
C2248 VDD.n107 VSS 0.05973f
C2249 VDD.n108 VSS 0.01714f
C2250 VDD.t589 VSS 0.10784f
C2251 VDD.t591 VSS 0.10603f
C2252 VDD.n109 VSS 0.05973f
C2253 VDD.n110 VSS 0.06691f
C2254 VDD.n111 VSS 1.21937f
C2255 VDD.t295 VSS 0.10919f
C2256 VDD.t517 VSS 0.11106f
C2257 VDD.n112 VSS 0.0602f
C2258 VDD.t39 VSS 0.10919f
C2259 VDD.t293 VSS 0.10919f
C2260 VDD.n113 VSS 0.05973f
C2261 VDD.n114 VSS 0.03027f
C2262 VDD.t35 VSS 0.10919f
C2263 VDD.t37 VSS 0.10919f
C2264 VDD.n115 VSS 0.05973f
C2265 VDD.n116 VSS 0.01714f
C2266 VDD.t297 VSS 0.11106f
C2267 VDD.t33 VSS 0.10919f
C2268 VDD.n117 VSS 0.05973f
C2269 VDD.n118 VSS 0.06691f
C2270 VDD.n119 VSS 0.7933f
C2271 VDD.t1 VSS 0.11108f
C2272 VDD.t249 VSS 0.11299f
C2273 VDD.n120 VSS 0.0602f
C2274 VDD.t123 VSS 0.11108f
C2275 VDD.t575 VSS 0.11108f
C2276 VDD.n121 VSS 0.05973f
C2277 VDD.n122 VSS 0.03027f
C2278 VDD.t519 VSS 0.11108f
C2279 VDD.t115 VSS 0.11108f
C2280 VDD.n123 VSS 0.05973f
C2281 VDD.n124 VSS 0.01714f
C2282 VDD.t41 VSS 0.11299f
C2283 VDD.t23 VSS 0.11108f
C2284 VDD.n125 VSS 0.05973f
C2285 VDD.n126 VSS 0.06691f
C2286 VDD.n127 VSS 0.65127f
C2287 VDD.t581 VSS 0.10705f
C2288 VDD.t117 VSS 0.10888f
C2289 VDD.n128 VSS 0.0602f
C2290 VDD.t247 VSS 0.10705f
C2291 VDD.t179 VSS 0.10705f
C2292 VDD.n129 VSS 0.05973f
C2293 VDD.n130 VSS 0.03027f
C2294 VDD.t207 VSS 0.10705f
C2295 VDD.t77 VSS 0.10705f
C2296 VDD.n131 VSS 0.05973f
C2297 VDD.n132 VSS 0.01714f
C2298 VDD.t129 VSS 0.10888f
C2299 VDD.t259 VSS 0.10705f
C2300 VDD.n133 VSS 0.05973f
C2301 VDD.n134 VSS 0.06691f
C2302 VDD.n135 VSS 0.65127f
C2303 VDD.t275 VSS 0.0833f
C2304 VDD.t273 VSS 0.08467f
C2305 VDD.n136 VSS 0.0602f
C2306 VDD.t267 VSS 0.08467f
C2307 VDD.t261 VSS 0.0833f
C2308 VDD.n137 VSS 0.05973f
C2309 VDD.n138 VSS 0.08004f
C2310 VDD.n139 VSS 0.58026f
C2311 VDD.t227 VSS 0.07074f
C2312 VDD.t225 VSS 0.07187f
C2313 VDD.n140 VSS 0.0602f
C2314 VDD.t231 VSS 0.07187f
C2315 VDD.t229 VSS 0.07074f
C2316 VDD.n141 VSS 0.05973f
C2317 VDD.n142 VSS 0.08004f
C2318 VDD.n143 VSS 0.50925f
C2319 VDD.t265 VSS 0.0833f
C2320 VDD.t263 VSS 0.08467f
C2321 VDD.n144 VSS 0.0602f
C2322 VDD.t269 VSS 0.08467f
C2323 VDD.t271 VSS 0.0833f
C2324 VDD.n145 VSS 0.05973f
C2325 VDD.n146 VSS 0.08004f
C2326 VDD.n147 VSS 0.71751f
C2327 VDD.n148 VSS 72.2659f
C2328 VDD.n149 VSS 0.12174p
C2329 VDD.t168 VSS 3.30973f
C2330 VDD.t146 VSS 0.16067f
C2331 VDD.t148 VSS 0.16067f
C2332 VDD.t14 VSS 0.16067f
C2333 VDD.t16 VSS 0.16067f
C2334 VDD.t70 VSS 0.16067f
C2335 VDD.t72 VSS 0.16067f
C2336 VDD.t164 VSS 0.16067f
C2337 VDD.t166 VSS 0.16067f
C2338 VDD.t142 VSS 0.16067f
C2339 VDD.t144 VSS 0.16067f
C2340 VDD.t10 VSS 0.16067f
C2341 VDD.t12 VSS 0.16067f
C2342 VDD.t66 VSS 0.16067f
C2343 VDD.t68 VSS 0.16067f
C2344 VDD.t160 VSS 0.16067f
C2345 VDD.t162 VSS 0.16067f
C2346 VDD.t138 VSS 0.16067f
C2347 VDD.t140 VSS 0.16067f
C2348 VDD.t6 VSS 0.16067f
C2349 VDD.t8 VSS 0.16067f
C2350 VDD.t62 VSS 0.16067f
C2351 VDD.t64 VSS 0.16067f
C2352 VDD.t156 VSS 0.16067f
C2353 VDD.t158 VSS 0.16067f
C2354 VDD.t134 VSS 0.16067f
C2355 VDD.t136 VSS 0.16067f
C2356 VDD.t398 VSS 0.16067f
C2357 VDD.t400 VSS 0.16067f
C2358 VDD.t500 VSS 0.16067f
C2359 VDD.t502 VSS 0.16067f
C2360 VDD.t508 VSS 0.16067f
C2361 VDD.t510 VSS 0.16067f
C2362 VDD.t390 VSS 0.16067f
C2363 VDD.t392 VSS 0.16067f
C2364 VDD.t536 VSS 0.16067f
C2365 VDD.t538 VSS 0.16067f
C2366 VDD.t570 VSS 0.16067f
C2367 VDD.t572 VSS 0.16067f
C2368 VDD.t394 VSS 0.16067f
C2369 VDD.t396 VSS 0.16067f
C2370 VDD.t496 VSS 0.16067f
C2371 VDD.t498 VSS 0.16067f
C2372 VDD.t512 VSS 0.16067f
C2373 VDD.t514 VSS 0.16067f
C2374 VDD.t386 VSS 0.16067f
C2375 VDD.t388 VSS 0.16067f
C2376 VDD.t532 VSS 0.16067f
C2377 VDD.t534 VSS 0.16067f
C2378 VDD.t566 VSS 0.16067f
C2379 VDD.t568 VSS 0.16067f
C2380 VDD.t288 VSS 0.16067f
C2381 VDD.t290 VSS 0.16067f
C2382 VDD.t492 VSS 0.16067f
C2383 VDD.t494 VSS 0.16067f
C2384 VDD.t504 VSS 0.16067f
C2385 VDD.t506 VSS 0.16067f
C2386 VDD.t282 VSS 0.16067f
C2387 VDD.t284 VSS 0.16067f
C2388 VDD.t528 VSS 0.16067f
C2389 VDD.t530 VSS 0.16067f
C2390 VDD.t562 VSS 0.16067f
C2391 VDD.t564 VSS 0.16067f
C2392 VDD.t286 VSS 0.89973f
C2393 VDD.t240 VSS 0.89973f
C2394 VDD.t150 VSS 0.16067f
C2395 VDD.t238 VSS 0.16067f
C2396 VDD.t90 VSS 0.16067f
C2397 VDD.t60 VSS 0.16067f
C2398 VDD.t280 VSS 0.16067f
C2399 VDD.t204 VSS 0.16067f
C2400 VDD.t586 VSS 0.16067f
C2401 VDD.t58 VSS 0.16067f
C2402 VDD.t522 VSS 0.16067f
C2403 VDD.t188 VSS 0.16067f
C2404 VDD.t236 VSS 0.16067f
C2405 VDD.t24 VSS 0.16067f
C2406 VDD.t86 VSS 0.16067f
C2407 VDD.t198 VSS 0.16067f
C2408 VDD.t104 VSS 0.16067f
C2409 VDD.t182 VSS 0.16067f
C2410 VDD.t180 VSS 0.16067f
C2411 VDD.t490 VSS 0.16067f
C2412 VDD.t100 VSS 0.16067f
C2413 VDD.t520 VSS 0.16067f
C2414 VDD.t106 VSS 0.16067f
C2415 VDD.t54 VSS 0.16067f
C2416 VDD.t108 VSS 0.16067f
C2417 VDD.t102 VSS 0.16067f
C2418 VDD.t582 VSS 0.16067f
C2419 VDD.t30 VSS 0.16067f
C2420 VDD.t28 VSS 0.16067f
C2421 VDD.t52 VSS 0.16067f
C2422 VDD.t56 VSS 0.16067f
C2423 VDD.t88 VSS 0.16067f
C2424 VDD.t544 VSS 0.89973f
C2425 VDD.t130 VSS 0.89973f
C2426 VDD.t132 VSS 0.16067f
C2427 VDD.t190 VSS 0.16067f
C2428 VDD.t192 VSS 0.16067f
C2429 VDD.t42 VSS 0.16067f
C2430 VDD.t44 VSS 0.16067f
C2431 VDD.t78 VSS 0.16067f
C2432 VDD.t80 VSS 0.16067f
C2433 VDD.t92 VSS 0.16067f
C2434 VDD.t94 VSS 0.16067f
C2435 VDD.t2 VSS 0.16067f
C2436 VDD.t4 VSS 0.16067f
C2437 VDD.t184 VSS 0.16067f
C2438 VDD.t186 VSS 0.16067f
C2439 VDD.t276 VSS 0.16067f
C2440 VDD.t278 VSS 0.89973f
C2441 VDD.t194 VSS 0.89973f
C2442 VDD.t196 VSS 0.16067f
C2443 VDD.t118 VSS 0.16067f
C2444 VDD.t120 VSS 0.16067f
C2445 VDD.t46 VSS 0.16067f
C2446 VDD.t48 VSS 0.16067f
C2447 VDD.t18 VSS 0.16067f
C2448 VDD.t20 VSS 0.89973f
C2449 VDD.t50 VSS 0.89973f
C2450 VDD.t82 VSS 0.16067f
C2451 VDD.t84 VSS 0.16067f
C2452 VDD.t96 VSS 0.16067f
C2453 VDD.t98 VSS 0.16067f
C2454 VDD.t232 VSS 0.16067f
C2455 VDD.t234 VSS 0.16067f
C2456 VDD.t26 VSS 0.89973f
C2457 VDD.t74 VSS 0.89973f
C2458 VDD.t200 VSS 0.16067f
C2459 VDD.t202 VSS 0.16067f
C2460 VDD.t546 VSS 0.16067f
C2461 VDD.t548 VSS 0.16067f
C2462 VDD.t250 VSS 0.16067f
C2463 VDD.t252 VSS 0.16067f
C2464 VDD.t584 VSS 0.89973f
C2465 VDD.t208 VSS 0.89973f
C2466 VDD.t222 VSS 0.16067f
C2467 VDD.t210 VSS 0.16067f
C2468 VDD.t212 VSS 0.89973f
C2469 VDD.t176 VSS 0.89973f
C2470 VDD.t174 VSS 0.16067f
C2471 VDD.t172 VSS 0.16067f
C2472 VDD.t170 VSS 0.89973f
C2473 VDD.t220 VSS 0.89973f
C2474 VDD.t214 VSS 0.16067f
C2475 VDD.t216 VSS 0.16067f
C2476 VDD.t218 VSS 0.90052f
C2477 VDD.t565 VSS 0.10783f
C2478 VDD.t287 VSS 0.10968f
C2479 VDD.n150 VSS 0.0602f
C2480 VDD.t531 VSS 0.10783f
C2481 VDD.t563 VSS 0.10783f
C2482 VDD.n151 VSS 0.05973f
C2483 VDD.n152 VSS 0.03027f
C2484 VDD.t285 VSS 0.10783f
C2485 VDD.t529 VSS 0.10783f
C2486 VDD.n153 VSS 0.05973f
C2487 VDD.n154 VSS 0.01714f
C2488 VDD.t507 VSS 0.10783f
C2489 VDD.t283 VSS 0.10783f
C2490 VDD.n155 VSS 0.05973f
C2491 VDD.n156 VSS 0.01714f
C2492 VDD.t495 VSS 0.10783f
C2493 VDD.t505 VSS 0.10783f
C2494 VDD.n157 VSS 0.05973f
C2495 VDD.n158 VSS 0.01714f
C2496 VDD.t291 VSS 0.10783f
C2497 VDD.t493 VSS 0.10783f
C2498 VDD.n159 VSS 0.05973f
C2499 VDD.n160 VSS 0.01714f
C2500 VDD.t569 VSS 0.10783f
C2501 VDD.t289 VSS 0.10783f
C2502 VDD.n161 VSS 0.05973f
C2503 VDD.n162 VSS 0.01714f
C2504 VDD.t535 VSS 0.10783f
C2505 VDD.t567 VSS 0.10783f
C2506 VDD.n163 VSS 0.05973f
C2507 VDD.n164 VSS 0.01714f
C2508 VDD.t389 VSS 0.10783f
C2509 VDD.t533 VSS 0.10783f
C2510 VDD.n165 VSS 0.05973f
C2511 VDD.n166 VSS 0.01714f
C2512 VDD.t515 VSS 0.10783f
C2513 VDD.t387 VSS 0.10783f
C2514 VDD.n167 VSS 0.05973f
C2515 VDD.n168 VSS 0.01714f
C2516 VDD.t499 VSS 0.10783f
C2517 VDD.t513 VSS 0.10783f
C2518 VDD.n169 VSS 0.05973f
C2519 VDD.n170 VSS 0.01714f
C2520 VDD.t397 VSS 0.10783f
C2521 VDD.t497 VSS 0.10783f
C2522 VDD.n171 VSS 0.05973f
C2523 VDD.n172 VSS 0.01714f
C2524 VDD.t573 VSS 0.10783f
C2525 VDD.t395 VSS 0.10783f
C2526 VDD.n173 VSS 0.05973f
C2527 VDD.n174 VSS 0.01714f
C2528 VDD.t539 VSS 0.10783f
C2529 VDD.t571 VSS 0.10783f
C2530 VDD.n175 VSS 0.05973f
C2531 VDD.n176 VSS 0.01714f
C2532 VDD.t393 VSS 0.10783f
C2533 VDD.t537 VSS 0.10783f
C2534 VDD.n177 VSS 0.05973f
C2535 VDD.n178 VSS 0.01714f
C2536 VDD.t511 VSS 0.10783f
C2537 VDD.t391 VSS 0.10783f
C2538 VDD.n179 VSS 0.05973f
C2539 VDD.n180 VSS 0.01714f
C2540 VDD.t503 VSS 0.10783f
C2541 VDD.t509 VSS 0.10783f
C2542 VDD.n181 VSS 0.05973f
C2543 VDD.n182 VSS 0.01714f
C2544 VDD.t401 VSS 0.10783f
C2545 VDD.t501 VSS 0.10783f
C2546 VDD.n183 VSS 0.05973f
C2547 VDD.n184 VSS 0.01714f
C2548 VDD.t137 VSS 0.10783f
C2549 VDD.t399 VSS 0.10783f
C2550 VDD.n185 VSS 0.05973f
C2551 VDD.n186 VSS 0.01714f
C2552 VDD.t159 VSS 0.10783f
C2553 VDD.t135 VSS 0.10783f
C2554 VDD.n187 VSS 0.05973f
C2555 VDD.n188 VSS 0.01714f
C2556 VDD.t65 VSS 0.10783f
C2557 VDD.t157 VSS 0.10783f
C2558 VDD.n189 VSS 0.05973f
C2559 VDD.n190 VSS 0.01714f
C2560 VDD.t9 VSS 0.10783f
C2561 VDD.t63 VSS 0.10783f
C2562 VDD.n191 VSS 0.05973f
C2563 VDD.n192 VSS 0.01714f
C2564 VDD.t141 VSS 0.10783f
C2565 VDD.t7 VSS 0.10783f
C2566 VDD.n193 VSS 0.05973f
C2567 VDD.n194 VSS 0.01714f
C2568 VDD.t163 VSS 0.10783f
C2569 VDD.t139 VSS 0.10783f
C2570 VDD.n195 VSS 0.05973f
C2571 VDD.n196 VSS 0.01714f
C2572 VDD.t69 VSS 0.10783f
C2573 VDD.t161 VSS 0.10783f
C2574 VDD.n197 VSS 0.05973f
C2575 VDD.n198 VSS 0.01714f
C2576 VDD.t13 VSS 0.10783f
C2577 VDD.t67 VSS 0.10783f
C2578 VDD.n199 VSS 0.05973f
C2579 VDD.n200 VSS 0.01714f
C2580 VDD.t145 VSS 0.10783f
C2581 VDD.t11 VSS 0.10783f
C2582 VDD.n201 VSS 0.05973f
C2583 VDD.n202 VSS 0.01714f
C2584 VDD.t167 VSS 0.10783f
C2585 VDD.t143 VSS 0.10783f
C2586 VDD.n203 VSS 0.05973f
C2587 VDD.n204 VSS 0.01714f
C2588 VDD.t73 VSS 0.10783f
C2589 VDD.t165 VSS 0.10783f
C2590 VDD.n205 VSS 0.05973f
C2591 VDD.n206 VSS 0.01714f
C2592 VDD.t17 VSS 0.10783f
C2593 VDD.t71 VSS 0.10783f
C2594 VDD.n207 VSS 0.05973f
C2595 VDD.n208 VSS 0.01714f
C2596 VDD.t149 VSS 0.10783f
C2597 VDD.t15 VSS 0.10783f
C2598 VDD.n209 VSS 0.05973f
C2599 VDD.n210 VSS 0.01714f
C2600 VDD.t169 VSS 0.10968f
C2601 VDD.t147 VSS 0.10783f
C2602 VDD.n211 VSS 0.05973f
C2603 VDD.n212 VSS 0.21014f
C2604 VDD.t89 VSS 0.10602f
C2605 VDD.t545 VSS 0.10783f
C2606 VDD.n213 VSS 0.0602f
C2607 VDD.t53 VSS 0.10602f
C2608 VDD.t57 VSS 0.10602f
C2609 VDD.n214 VSS 0.05973f
C2610 VDD.n215 VSS 0.03027f
C2611 VDD.t31 VSS 0.10602f
C2612 VDD.t29 VSS 0.10602f
C2613 VDD.n216 VSS 0.05973f
C2614 VDD.n217 VSS 0.01714f
C2615 VDD.t103 VSS 0.10602f
C2616 VDD.t583 VSS 0.10602f
C2617 VDD.n218 VSS 0.05973f
C2618 VDD.n219 VSS 0.01714f
C2619 VDD.t55 VSS 0.10602f
C2620 VDD.t109 VSS 0.10602f
C2621 VDD.n220 VSS 0.05973f
C2622 VDD.n221 VSS 0.01714f
C2623 VDD.t521 VSS 0.10602f
C2624 VDD.t107 VSS 0.10602f
C2625 VDD.n222 VSS 0.05973f
C2626 VDD.n223 VSS 0.01714f
C2627 VDD.t491 VSS 0.10602f
C2628 VDD.t101 VSS 0.10602f
C2629 VDD.n224 VSS 0.05973f
C2630 VDD.n225 VSS 0.01714f
C2631 VDD.t183 VSS 0.10602f
C2632 VDD.t181 VSS 0.10602f
C2633 VDD.n226 VSS 0.05973f
C2634 VDD.n227 VSS 0.01714f
C2635 VDD.t199 VSS 0.10602f
C2636 VDD.t105 VSS 0.10602f
C2637 VDD.n228 VSS 0.05973f
C2638 VDD.n229 VSS 0.01714f
C2639 VDD.t25 VSS 0.10602f
C2640 VDD.t87 VSS 0.10602f
C2641 VDD.n230 VSS 0.05973f
C2642 VDD.n231 VSS 0.01714f
C2643 VDD.t189 VSS 0.10602f
C2644 VDD.t237 VSS 0.10602f
C2645 VDD.n232 VSS 0.05973f
C2646 VDD.n233 VSS 0.01714f
C2647 VDD.t59 VSS 0.10602f
C2648 VDD.t523 VSS 0.10602f
C2649 VDD.n234 VSS 0.05973f
C2650 VDD.n235 VSS 0.01714f
C2651 VDD.t205 VSS 0.10602f
C2652 VDD.t587 VSS 0.10602f
C2653 VDD.n236 VSS 0.05973f
C2654 VDD.n237 VSS 0.01714f
C2655 VDD.t61 VSS 0.10602f
C2656 VDD.t281 VSS 0.10602f
C2657 VDD.n238 VSS 0.05973f
C2658 VDD.n239 VSS 0.01714f
C2659 VDD.t239 VSS 0.10602f
C2660 VDD.t91 VSS 0.10602f
C2661 VDD.n240 VSS 0.05973f
C2662 VDD.n241 VSS 0.01714f
C2663 VDD.t241 VSS 0.10783f
C2664 VDD.t151 VSS 0.10602f
C2665 VDD.n242 VSS 0.05973f
C2666 VDD.n243 VSS 0.06691f
C2667 VDD.n244 VSS 3.28526f
C2668 VDD.t277 VSS 0.10603f
C2669 VDD.t279 VSS 0.10784f
C2670 VDD.n245 VSS 0.0602f
C2671 VDD.t185 VSS 0.10603f
C2672 VDD.t187 VSS 0.10603f
C2673 VDD.n246 VSS 0.05973f
C2674 VDD.n247 VSS 0.03027f
C2675 VDD.t3 VSS 0.10603f
C2676 VDD.t5 VSS 0.10603f
C2677 VDD.n248 VSS 0.05973f
C2678 VDD.n249 VSS 0.01714f
C2679 VDD.t93 VSS 0.10603f
C2680 VDD.t95 VSS 0.10603f
C2681 VDD.n250 VSS 0.05973f
C2682 VDD.n251 VSS 0.01714f
C2683 VDD.t79 VSS 0.10603f
C2684 VDD.t81 VSS 0.10603f
C2685 VDD.n252 VSS 0.05973f
C2686 VDD.n253 VSS 0.01714f
C2687 VDD.t43 VSS 0.10603f
C2688 VDD.t45 VSS 0.10603f
C2689 VDD.n254 VSS 0.05973f
C2690 VDD.n255 VSS 0.01714f
C2691 VDD.t191 VSS 0.10603f
C2692 VDD.t193 VSS 0.10603f
C2693 VDD.n256 VSS 0.05973f
C2694 VDD.n257 VSS 0.01714f
C2695 VDD.t131 VSS 0.10784f
C2696 VDD.t133 VSS 0.10603f
C2697 VDD.n258 VSS 0.05973f
C2698 VDD.n259 VSS 0.06691f
C2699 VDD.n260 VSS 1.21937f
C2700 VDD.t19 VSS 0.10919f
C2701 VDD.t21 VSS 0.11106f
C2702 VDD.n261 VSS 0.0602f
C2703 VDD.t47 VSS 0.10919f
C2704 VDD.t49 VSS 0.10919f
C2705 VDD.n262 VSS 0.05973f
C2706 VDD.n263 VSS 0.03027f
C2707 VDD.t119 VSS 0.10919f
C2708 VDD.t121 VSS 0.10919f
C2709 VDD.n264 VSS 0.05973f
C2710 VDD.n265 VSS 0.01714f
C2711 VDD.t195 VSS 0.11106f
C2712 VDD.t197 VSS 0.10919f
C2713 VDD.n266 VSS 0.05973f
C2714 VDD.n267 VSS 0.06691f
C2715 VDD.n268 VSS 0.7933f
C2716 VDD.t235 VSS 0.11108f
C2717 VDD.t27 VSS 0.11299f
C2718 VDD.n269 VSS 0.0602f
C2719 VDD.t99 VSS 0.11108f
C2720 VDD.t233 VSS 0.11108f
C2721 VDD.n270 VSS 0.05973f
C2722 VDD.n271 VSS 0.03027f
C2723 VDD.t85 VSS 0.11108f
C2724 VDD.t97 VSS 0.11108f
C2725 VDD.n272 VSS 0.05973f
C2726 VDD.n273 VSS 0.01714f
C2727 VDD.t51 VSS 0.11299f
C2728 VDD.t83 VSS 0.11108f
C2729 VDD.n274 VSS 0.05973f
C2730 VDD.n275 VSS 0.06691f
C2731 VDD.n276 VSS 0.65127f
C2732 VDD.t253 VSS 0.10705f
C2733 VDD.t585 VSS 0.10888f
C2734 VDD.n277 VSS 0.0602f
C2735 VDD.t549 VSS 0.10705f
C2736 VDD.t251 VSS 0.10705f
C2737 VDD.n278 VSS 0.05973f
C2738 VDD.n279 VSS 0.03027f
C2739 VDD.t203 VSS 0.10705f
C2740 VDD.t547 VSS 0.10705f
C2741 VDD.n280 VSS 0.05973f
C2742 VDD.n281 VSS 0.01714f
C2743 VDD.t75 VSS 0.10888f
C2744 VDD.t201 VSS 0.10705f
C2745 VDD.n282 VSS 0.05973f
C2746 VDD.n283 VSS 0.06691f
C2747 VDD.n284 VSS 0.65127f
C2748 VDD.t211 VSS 0.08191f
C2749 VDD.t213 VSS 0.08326f
C2750 VDD.n285 VSS 0.0602f
C2751 VDD.t209 VSS 0.08326f
C2752 VDD.t223 VSS 0.08191f
C2753 VDD.n286 VSS 0.05973f
C2754 VDD.n287 VSS 0.08004f
C2755 VDD.n288 VSS 0.58026f
C2756 VDD.t173 VSS 0.07074f
C2757 VDD.t171 VSS 0.07187f
C2758 VDD.n289 VSS 0.0602f
C2759 VDD.t177 VSS 0.07187f
C2760 VDD.t175 VSS 0.07074f
C2761 VDD.n290 VSS 0.05973f
C2762 VDD.n291 VSS 0.08004f
C2763 VDD.n292 VSS 0.50925f
C2764 VDD.t217 VSS 0.08191f
C2765 VDD.t219 VSS 0.08326f
C2766 VDD.n293 VSS 0.0602f
C2767 VDD.t221 VSS 0.08326f
C2768 VDD.t215 VSS 0.08191f
C2769 VDD.n294 VSS 0.05973f
C2770 VDD.n295 VSS 0.08004f
C2771 VDD.n296 VSS 0.71751f
C2772 VDD.n297 VSS 71.5081f
C2773 VDD.n298 VSS 0.1225p
C2774 VDD.n300 VSS 0.01604f
C2775 CLKN_HB.n0 VSS 0.06668f
C2776 CLKN_HB.n1 VSS 0.07251f
C2777 CLKN_HB.n2 VSS 0.07251f
C2778 CLKN_HB.n3 VSS 0.06668f
C2779 CLKN_HB.n4 VSS 0.31829f
C2780 CLKN_HB.n5 VSS 0.06668f
C2781 CLKN_HB.n6 VSS 0.07251f
C2782 CLKN_HB.n7 VSS 0.07251f
C2783 CLKN_HB.n8 VSS 0.06668f
C2784 CLKN_HB.n9 VSS 0.25724f
C2785 CLKN_HB.n10 VSS 0.84855f
C2786 CLKN_HB.n11 VSS 0.06668f
C2787 CLKN_HB.n12 VSS 0.07251f
C2788 CLKN_HB.n13 VSS 0.07251f
C2789 CLKN_HB.n14 VSS 0.06668f
C2790 CLKN_HB.n15 VSS 0.31829f
C2791 CLKN_HB.n16 VSS 0.06668f
C2792 CLKN_HB.n17 VSS 0.07251f
C2793 CLKN_HB.n18 VSS 0.07251f
C2794 CLKN_HB.n19 VSS 0.06668f
C2795 CLKN_HB.n20 VSS 0.25724f
C2796 CLKN_HB.n21 VSS 0.65701f
C2797 CLKN_HB.n22 VSS 1.26047f
C2798 CLKN_H.n0 VSS 0.05609f
C2799 CLKN_H.n1 VSS 0.06099f
C2800 CLKN_H.n2 VSS 0.06099f
C2801 CLKN_H.n3 VSS 0.05609f
C2802 CLKN_H.n4 VSS 0.26774f
C2803 CLKN_H.n5 VSS 0.05609f
C2804 CLKN_H.n6 VSS 0.06099f
C2805 CLKN_H.n7 VSS 0.06099f
C2806 CLKN_H.n8 VSS 0.05609f
C2807 CLKN_H.n9 VSS 0.21639f
C2808 CLKN_H.n10 VSS 1.63645f
C2809 O_CAPTURE_CLKB.t5 VSS 1.05925f
C2810 O_CAPTURE_CLKB.t8 VSS 0.24629f
C2811 O_CAPTURE_CLKB.t9 VSS 0.24629f
C2812 O_CAPTURE_CLKB.n0 VSS 0.78051f
C2813 O_CAPTURE_CLKB.n1 VSS 0.42902f
C2814 O_CAPTURE_CLKB.t13 VSS 0.24629f
C2815 O_CAPTURE_CLKB.t14 VSS 0.24629f
C2816 O_CAPTURE_CLKB.n2 VSS 0.78051f
C2817 O_CAPTURE_CLKB.n3 VSS 0.22396f
C2818 O_CAPTURE_CLKB.t10 VSS 0.24629f
C2819 O_CAPTURE_CLKB.t11 VSS 0.24629f
C2820 O_CAPTURE_CLKB.n4 VSS 0.78051f
C2821 O_CAPTURE_CLKB.n5 VSS 0.22396f
C2822 O_CAPTURE_CLKB.t15 VSS 1.05224f
C2823 O_CAPTURE_CLKB.n6 VSS 0.46336f
C2824 O_CAPTURE_CLKB.t12 VSS 1.05738f
C2825 O_CAPTURE_CLKB.t6 VSS 0.24629f
C2826 O_CAPTURE_CLKB.t3 VSS 0.24629f
C2827 O_CAPTURE_CLKB.n7 VSS 0.77475f
C2828 O_CAPTURE_CLKB.n8 VSS 0.43664f
C2829 O_CAPTURE_CLKB.t2 VSS 0.24629f
C2830 O_CAPTURE_CLKB.t7 VSS 0.24629f
C2831 O_CAPTURE_CLKB.n9 VSS 0.77475f
C2832 O_CAPTURE_CLKB.n10 VSS 0.22971f
C2833 O_CAPTURE_CLKB.t0 VSS 0.24629f
C2834 O_CAPTURE_CLKB.t1 VSS 0.24629f
C2835 O_CAPTURE_CLKB.n11 VSS 0.77475f
C2836 O_CAPTURE_CLKB.n12 VSS 0.22971f
C2837 O_CAPTURE_CLKB.t4 VSS 1.05037f
C2838 O_CAPTURE_CLKB.n13 VSS 0.31419f
C2839 O_CAPTURE_CLKB.n14 VSS 1.0083f
C2840 O_CAPTURE_CLK.t2 VSS 1.0209f
C2841 O_CAPTURE_CLK.t3 VSS 0.24367f
C2842 O_CAPTURE_CLK.t4 VSS 0.24367f
C2843 O_CAPTURE_CLK.n0 VSS 0.74605f
C2844 O_CAPTURE_CLK.n1 VSS 0.41008f
C2845 O_CAPTURE_CLK.t5 VSS 0.24367f
C2846 O_CAPTURE_CLK.t6 VSS 0.24367f
C2847 O_CAPTURE_CLK.n2 VSS 0.74605f
C2848 O_CAPTURE_CLK.n3 VSS 0.21407f
C2849 O_CAPTURE_CLK.t11 VSS 0.24367f
C2850 O_CAPTURE_CLK.t12 VSS 0.24367f
C2851 O_CAPTURE_CLK.n4 VSS 0.74605f
C2852 O_CAPTURE_CLK.n5 VSS 0.21407f
C2853 O_CAPTURE_CLK.t0 VSS 1.0142f
C2854 O_CAPTURE_CLK.n6 VSS 0.44291f
C2855 O_CAPTURE_CLK.t15 VSS 1.01912f
C2856 O_CAPTURE_CLK.t9 VSS 0.24367f
C2857 O_CAPTURE_CLK.t10 VSS 0.24367f
C2858 O_CAPTURE_CLK.n7 VSS 0.74055f
C2859 O_CAPTURE_CLK.n8 VSS 0.41736f
C2860 O_CAPTURE_CLK.t13 VSS 0.24367f
C2861 O_CAPTURE_CLK.t14 VSS 0.24367f
C2862 O_CAPTURE_CLK.n9 VSS 0.74055f
C2863 O_CAPTURE_CLK.n10 VSS 0.21957f
C2864 O_CAPTURE_CLK.t7 VSS 0.24367f
C2865 O_CAPTURE_CLK.t8 VSS 0.24367f
C2866 O_CAPTURE_CLK.n11 VSS 0.74055f
C2867 O_CAPTURE_CLK.n12 VSS 0.21957f
C2868 O_CAPTURE_CLK.t1 VSS 1.01241f
C2869 O_CAPTURE_CLK.n13 VSS 0.30032f
C2870 O_CAPTURE_CLK.n14 VSS 1.53504f
C2871 O_SENSE.t57 VSS 1.13059f
C2872 O_SENSE.t42 VSS 0.25814f
C2873 O_SENSE.t43 VSS 0.25814f
C2874 O_SENSE.n0 VSS 0.83775f
C2875 O_SENSE.n1 VSS 0.46048f
C2876 O_SENSE.t4 VSS 0.25814f
C2877 O_SENSE.t5 VSS 0.25814f
C2878 O_SENSE.n2 VSS 0.83775f
C2879 O_SENSE.n3 VSS 0.24038f
C2880 O_SENSE.t22 VSS 0.25814f
C2881 O_SENSE.t23 VSS 0.25814f
C2882 O_SENSE.n4 VSS 0.83775f
C2883 O_SENSE.n5 VSS 0.24038f
C2884 O_SENSE.t54 VSS 0.25814f
C2885 O_SENSE.t55 VSS 0.25814f
C2886 O_SENSE.n6 VSS 0.83775f
C2887 O_SENSE.n7 VSS 0.24038f
C2888 O_SENSE.t40 VSS 0.25814f
C2889 O_SENSE.t41 VSS 0.25814f
C2890 O_SENSE.n8 VSS 0.83775f
C2891 O_SENSE.n9 VSS 0.24038f
C2892 O_SENSE.t2 VSS 0.25814f
C2893 O_SENSE.t3 VSS 0.25814f
C2894 O_SENSE.n10 VSS 0.83775f
C2895 O_SENSE.n11 VSS 0.24038f
C2896 O_SENSE.t20 VSS 0.25814f
C2897 O_SENSE.t21 VSS 0.25814f
C2898 O_SENSE.n12 VSS 0.83775f
C2899 O_SENSE.n13 VSS 0.24038f
C2900 O_SENSE.t52 VSS 0.25814f
C2901 O_SENSE.t53 VSS 0.25814f
C2902 O_SENSE.n14 VSS 0.83775f
C2903 O_SENSE.n15 VSS 0.24038f
C2904 O_SENSE.t38 VSS 0.25814f
C2905 O_SENSE.t39 VSS 0.25814f
C2906 O_SENSE.n16 VSS 0.83775f
C2907 O_SENSE.n17 VSS 0.24038f
C2908 O_SENSE.t0 VSS 0.25814f
C2909 O_SENSE.t1 VSS 0.25814f
C2910 O_SENSE.n18 VSS 0.83775f
C2911 O_SENSE.n19 VSS 0.24038f
C2912 O_SENSE.t18 VSS 0.25814f
C2913 O_SENSE.t19 VSS 0.25814f
C2914 O_SENSE.n20 VSS 0.83775f
C2915 O_SENSE.n21 VSS 0.24038f
C2916 O_SENSE.t50 VSS 0.25814f
C2917 O_SENSE.t51 VSS 0.25814f
C2918 O_SENSE.n22 VSS 0.83775f
C2919 O_SENSE.n23 VSS 0.24038f
C2920 O_SENSE.t36 VSS 0.25814f
C2921 O_SENSE.t37 VSS 0.25814f
C2922 O_SENSE.n24 VSS 0.83775f
C2923 O_SENSE.n25 VSS 0.24038f
C2924 O_SENSE.t96 VSS 0.25814f
C2925 O_SENSE.t97 VSS 0.25814f
C2926 O_SENSE.n26 VSS 0.83775f
C2927 O_SENSE.n27 VSS 0.24038f
C2928 O_SENSE.t102 VSS 0.25814f
C2929 O_SENSE.t103 VSS 0.25814f
C2930 O_SENSE.n28 VSS 0.83775f
C2931 O_SENSE.n29 VSS 0.24038f
C2932 O_SENSE.t106 VSS 0.25814f
C2933 O_SENSE.t107 VSS 0.25814f
C2934 O_SENSE.n30 VSS 0.83775f
C2935 O_SENSE.n31 VSS 0.24038f
C2936 O_SENSE.t92 VSS 0.25814f
C2937 O_SENSE.t93 VSS 0.25814f
C2938 O_SENSE.n32 VSS 0.83775f
C2939 O_SENSE.n33 VSS 0.24038f
C2940 O_SENSE.t118 VSS 0.25814f
C2941 O_SENSE.t119 VSS 0.25814f
C2942 O_SENSE.n34 VSS 0.83775f
C2943 O_SENSE.n35 VSS 0.24038f
C2944 O_SENSE.t126 VSS 0.25814f
C2945 O_SENSE.t127 VSS 0.25814f
C2946 O_SENSE.n36 VSS 0.83775f
C2947 O_SENSE.n37 VSS 0.24038f
C2948 O_SENSE.t94 VSS 0.25814f
C2949 O_SENSE.t95 VSS 0.25814f
C2950 O_SENSE.n38 VSS 0.83775f
C2951 O_SENSE.n39 VSS 0.24038f
C2952 O_SENSE.t100 VSS 0.25814f
C2953 O_SENSE.t101 VSS 0.25814f
C2954 O_SENSE.n40 VSS 0.83775f
C2955 O_SENSE.n41 VSS 0.24038f
C2956 O_SENSE.t108 VSS 0.25814f
C2957 O_SENSE.t109 VSS 0.25814f
C2958 O_SENSE.n42 VSS 0.83775f
C2959 O_SENSE.n43 VSS 0.24038f
C2960 O_SENSE.t90 VSS 0.25814f
C2961 O_SENSE.t91 VSS 0.25814f
C2962 O_SENSE.n44 VSS 0.83775f
C2963 O_SENSE.n45 VSS 0.24038f
C2964 O_SENSE.t116 VSS 0.25814f
C2965 O_SENSE.t117 VSS 0.25814f
C2966 O_SENSE.n46 VSS 0.83775f
C2967 O_SENSE.n47 VSS 0.24038f
C2968 O_SENSE.t124 VSS 0.25814f
C2969 O_SENSE.t125 VSS 0.25814f
C2970 O_SENSE.n48 VSS 0.83775f
C2971 O_SENSE.n49 VSS 0.24038f
C2972 O_SENSE.t88 VSS 0.25814f
C2973 O_SENSE.t89 VSS 0.25814f
C2974 O_SENSE.n50 VSS 0.83775f
C2975 O_SENSE.n51 VSS 0.24038f
C2976 O_SENSE.t98 VSS 0.25814f
C2977 O_SENSE.t99 VSS 0.25814f
C2978 O_SENSE.n52 VSS 0.83775f
C2979 O_SENSE.n53 VSS 0.24038f
C2980 O_SENSE.t104 VSS 0.25814f
C2981 O_SENSE.t105 VSS 0.25814f
C2982 O_SENSE.n54 VSS 0.83775f
C2983 O_SENSE.n55 VSS 0.24038f
C2984 O_SENSE.t85 VSS 0.25814f
C2985 O_SENSE.t86 VSS 0.25814f
C2986 O_SENSE.n56 VSS 0.83775f
C2987 O_SENSE.n57 VSS 0.24038f
C2988 O_SENSE.t114 VSS 0.25814f
C2989 O_SENSE.t115 VSS 0.25814f
C2990 O_SENSE.n58 VSS 0.83775f
C2991 O_SENSE.n59 VSS 0.24038f
C2992 O_SENSE.t122 VSS 0.25814f
C2993 O_SENSE.t123 VSS 0.25814f
C2994 O_SENSE.n60 VSS 0.83775f
C2995 O_SENSE.n61 VSS 0.24038f
C2996 O_SENSE.t87 VSS 1.12307f
C2997 O_SENSE.n62 VSS 0.49734f
C2998 O_SENSE.t80 VSS 1.12859f
C2999 O_SENSE.t74 VSS 0.25814f
C3000 O_SENSE.t75 VSS 0.25814f
C3001 O_SENSE.n63 VSS 0.83157f
C3002 O_SENSE.n64 VSS 0.46866f
C3003 O_SENSE.t34 VSS 0.25814f
C3004 O_SENSE.t35 VSS 0.25814f
C3005 O_SENSE.n65 VSS 0.83157f
C3006 O_SENSE.n66 VSS 0.24656f
C3007 O_SENSE.t16 VSS 0.25814f
C3008 O_SENSE.t17 VSS 0.25814f
C3009 O_SENSE.n67 VSS 0.83157f
C3010 O_SENSE.n68 VSS 0.24656f
C3011 O_SENSE.t112 VSS 0.25814f
C3012 O_SENSE.t113 VSS 0.25814f
C3013 O_SENSE.n69 VSS 0.83157f
C3014 O_SENSE.n70 VSS 0.24656f
C3015 O_SENSE.t62 VSS 0.25814f
C3016 O_SENSE.t63 VSS 0.25814f
C3017 O_SENSE.n71 VSS 0.83157f
C3018 O_SENSE.n72 VSS 0.24656f
C3019 O_SENSE.t83 VSS 0.25814f
C3020 O_SENSE.t84 VSS 0.25814f
C3021 O_SENSE.n73 VSS 0.83157f
C3022 O_SENSE.n74 VSS 0.24656f
C3023 O_SENSE.t68 VSS 0.25814f
C3024 O_SENSE.t69 VSS 0.25814f
C3025 O_SENSE.n75 VSS 0.83157f
C3026 O_SENSE.n76 VSS 0.24656f
C3027 O_SENSE.t78 VSS 0.25814f
C3028 O_SENSE.t79 VSS 0.25814f
C3029 O_SENSE.n77 VSS 0.83157f
C3030 O_SENSE.n78 VSS 0.24656f
C3031 O_SENSE.t72 VSS 0.25814f
C3032 O_SENSE.t73 VSS 0.25814f
C3033 O_SENSE.n79 VSS 0.83157f
C3034 O_SENSE.n80 VSS 0.24656f
C3035 O_SENSE.t120 VSS 0.25814f
C3036 O_SENSE.t121 VSS 0.25814f
C3037 O_SENSE.n81 VSS 0.83157f
C3038 O_SENSE.n82 VSS 0.24656f
C3039 O_SENSE.t48 VSS 0.25814f
C3040 O_SENSE.t49 VSS 0.25814f
C3041 O_SENSE.n83 VSS 0.83157f
C3042 O_SENSE.n84 VSS 0.24656f
C3043 O_SENSE.t81 VSS 0.25814f
C3044 O_SENSE.t82 VSS 0.25814f
C3045 O_SENSE.n85 VSS 0.83157f
C3046 O_SENSE.n86 VSS 0.24656f
C3047 O_SENSE.t66 VSS 0.25814f
C3048 O_SENSE.t67 VSS 0.25814f
C3049 O_SENSE.n87 VSS 0.83157f
C3050 O_SENSE.n88 VSS 0.24656f
C3051 O_SENSE.t32 VSS 0.25814f
C3052 O_SENSE.t33 VSS 0.25814f
C3053 O_SENSE.n89 VSS 0.83157f
C3054 O_SENSE.n90 VSS 0.24656f
C3055 O_SENSE.t14 VSS 0.25814f
C3056 O_SENSE.t15 VSS 0.25814f
C3057 O_SENSE.n91 VSS 0.83157f
C3058 O_SENSE.n92 VSS 0.24656f
C3059 O_SENSE.t76 VSS 0.25814f
C3060 O_SENSE.t77 VSS 0.25814f
C3061 O_SENSE.n93 VSS 0.83157f
C3062 O_SENSE.n94 VSS 0.24656f
C3063 O_SENSE.t70 VSS 0.25814f
C3064 O_SENSE.t71 VSS 0.25814f
C3065 O_SENSE.n95 VSS 0.83157f
C3066 O_SENSE.n96 VSS 0.24656f
C3067 O_SENSE.t64 VSS 0.25814f
C3068 O_SENSE.t65 VSS 0.25814f
C3069 O_SENSE.n97 VSS 0.83157f
C3070 O_SENSE.n98 VSS 0.24656f
C3071 O_SENSE.t30 VSS 0.25814f
C3072 O_SENSE.t31 VSS 0.25814f
C3073 O_SENSE.n99 VSS 0.83157f
C3074 O_SENSE.n100 VSS 0.24656f
C3075 O_SENSE.t12 VSS 0.25814f
C3076 O_SENSE.t13 VSS 0.25814f
C3077 O_SENSE.n101 VSS 0.83157f
C3078 O_SENSE.n102 VSS 0.24656f
C3079 O_SENSE.t110 VSS 0.25814f
C3080 O_SENSE.t111 VSS 0.25814f
C3081 O_SENSE.n103 VSS 0.83157f
C3082 O_SENSE.n104 VSS 0.24656f
C3083 O_SENSE.t10 VSS 0.25814f
C3084 O_SENSE.t11 VSS 0.25814f
C3085 O_SENSE.n105 VSS 0.83157f
C3086 O_SENSE.n106 VSS 0.24656f
C3087 O_SENSE.t28 VSS 0.25814f
C3088 O_SENSE.t29 VSS 0.25814f
C3089 O_SENSE.n107 VSS 0.83157f
C3090 O_SENSE.n108 VSS 0.24656f
C3091 O_SENSE.t60 VSS 0.25814f
C3092 O_SENSE.t61 VSS 0.25814f
C3093 O_SENSE.n109 VSS 0.83157f
C3094 O_SENSE.n110 VSS 0.24656f
C3095 O_SENSE.t46 VSS 0.25814f
C3096 O_SENSE.t47 VSS 0.25814f
C3097 O_SENSE.n111 VSS 0.83157f
C3098 O_SENSE.n112 VSS 0.24656f
C3099 O_SENSE.t8 VSS 0.25814f
C3100 O_SENSE.t9 VSS 0.25814f
C3101 O_SENSE.n113 VSS 0.83157f
C3102 O_SENSE.n114 VSS 0.24656f
C3103 O_SENSE.t26 VSS 0.25814f
C3104 O_SENSE.t27 VSS 0.25814f
C3105 O_SENSE.n115 VSS 0.83157f
C3106 O_SENSE.n116 VSS 0.24656f
C3107 O_SENSE.t58 VSS 0.25814f
C3108 O_SENSE.t59 VSS 0.25814f
C3109 O_SENSE.n117 VSS 0.83157f
C3110 O_SENSE.n118 VSS 0.24656f
C3111 O_SENSE.t44 VSS 0.25814f
C3112 O_SENSE.t45 VSS 0.25814f
C3113 O_SENSE.n119 VSS 0.83157f
C3114 O_SENSE.n120 VSS 0.24656f
C3115 O_SENSE.t6 VSS 0.25814f
C3116 O_SENSE.t7 VSS 0.25814f
C3117 O_SENSE.n121 VSS 0.83157f
C3118 O_SENSE.n122 VSS 0.24656f
C3119 O_SENSE.t24 VSS 0.25814f
C3120 O_SENSE.t25 VSS 0.25814f
C3121 O_SENSE.n123 VSS 0.83157f
C3122 O_SENSE.n124 VSS 0.24656f
C3123 O_SENSE.t56 VSS 1.12106f
C3124 O_SENSE.n125 VSS 0.33723f
C3125 O_SENSE.n126 VSS 2.82208f
C3126 CLKP_HB.n0 VSS 0.06799f
C3127 CLKP_HB.n1 VSS 0.07393f
C3128 CLKP_HB.n2 VSS 0.07393f
C3129 CLKP_HB.n3 VSS 0.06799f
C3130 CLKP_HB.n4 VSS 0.32454f
C3131 CLKP_HB.n5 VSS 0.06799f
C3132 CLKP_HB.n6 VSS 0.07393f
C3133 CLKP_HB.n7 VSS 0.07393f
C3134 CLKP_HB.n8 VSS 0.06799f
C3135 CLKP_HB.n9 VSS 0.26229f
C3136 CLKP_HB.n10 VSS 0.8652f
C3137 CLKP_HB.n11 VSS 0.06799f
C3138 CLKP_HB.n12 VSS 0.07393f
C3139 CLKP_HB.n13 VSS 0.07393f
C3140 CLKP_HB.n14 VSS 0.06799f
C3141 CLKP_HB.n15 VSS 0.32454f
C3142 CLKP_HB.n16 VSS 0.06799f
C3143 CLKP_HB.n17 VSS 0.07393f
C3144 CLKP_HB.n18 VSS 0.07393f
C3145 CLKP_HB.n19 VSS 0.06799f
C3146 CLKP_HB.n20 VSS 0.26229f
C3147 CLKP_HB.n21 VSS 0.66991f
C3148 CLKP_HB.n22 VSS 1.19192f
C3149 CLKP_H.n0 VSS 0.05609f
C3150 CLKP_H.n1 VSS 0.06099f
C3151 CLKP_H.n2 VSS 0.06099f
C3152 CLKP_H.n3 VSS 0.05609f
C3153 CLKP_H.n4 VSS 0.26774f
C3154 CLKP_H.n5 VSS 0.05609f
C3155 CLKP_H.n6 VSS 0.06099f
C3156 CLKP_H.n7 VSS 0.06099f
C3157 CLKP_H.n8 VSS 0.05609f
C3158 CLKP_H.n9 VSS 0.21639f
C3159 CLKP_H.n10 VSS 1.63645f
C3160 E_CAPTURE_CLKB.t4 VSS 1.05925f
C3161 E_CAPTURE_CLKB.t11 VSS 0.24629f
C3162 E_CAPTURE_CLKB.t8 VSS 0.24629f
C3163 E_CAPTURE_CLKB.n0 VSS 0.78051f
C3164 E_CAPTURE_CLKB.n1 VSS 0.42902f
C3165 E_CAPTURE_CLKB.t2 VSS 0.24629f
C3166 E_CAPTURE_CLKB.t9 VSS 0.24629f
C3167 E_CAPTURE_CLKB.n2 VSS 0.78051f
C3168 E_CAPTURE_CLKB.n3 VSS 0.22396f
C3169 E_CAPTURE_CLKB.t7 VSS 0.24629f
C3170 E_CAPTURE_CLKB.t14 VSS 0.24629f
C3171 E_CAPTURE_CLKB.n4 VSS 0.78051f
C3172 E_CAPTURE_CLKB.n5 VSS 0.22396f
C3173 E_CAPTURE_CLKB.t3 VSS 1.05224f
C3174 E_CAPTURE_CLKB.n6 VSS 0.46336f
C3175 E_CAPTURE_CLKB.t6 VSS 1.05738f
C3176 E_CAPTURE_CLKB.t5 VSS 0.24629f
C3177 E_CAPTURE_CLKB.t13 VSS 0.24629f
C3178 E_CAPTURE_CLKB.n7 VSS 0.77475f
C3179 E_CAPTURE_CLKB.n8 VSS 0.43664f
C3180 E_CAPTURE_CLKB.t15 VSS 0.24629f
C3181 E_CAPTURE_CLKB.t12 VSS 0.24629f
C3182 E_CAPTURE_CLKB.n9 VSS 0.77475f
C3183 E_CAPTURE_CLKB.n10 VSS 0.22971f
C3184 E_CAPTURE_CLKB.t0 VSS 0.24629f
C3185 E_CAPTURE_CLKB.t10 VSS 0.24629f
C3186 E_CAPTURE_CLKB.n11 VSS 0.77475f
C3187 E_CAPTURE_CLKB.n12 VSS 0.22971f
C3188 E_CAPTURE_CLKB.t1 VSS 1.05037f
C3189 E_CAPTURE_CLKB.n13 VSS 0.31419f
C3190 E_CAPTURE_CLKB.n14 VSS 1.0083f
C3191 E_CAPTURE_CLK.t3 VSS 1.0209f
C3192 E_CAPTURE_CLK.t2 VSS 0.24367f
C3193 E_CAPTURE_CLK.t11 VSS 0.24367f
C3194 E_CAPTURE_CLK.n0 VSS 0.74605f
C3195 E_CAPTURE_CLK.n1 VSS 0.41008f
C3196 E_CAPTURE_CLK.t5 VSS 0.24367f
C3197 E_CAPTURE_CLK.t6 VSS 0.24367f
C3198 E_CAPTURE_CLK.n2 VSS 0.74605f
C3199 E_CAPTURE_CLK.n3 VSS 0.21407f
C3200 E_CAPTURE_CLK.t15 VSS 0.24367f
C3201 E_CAPTURE_CLK.t0 VSS 0.24367f
C3202 E_CAPTURE_CLK.n4 VSS 0.74605f
C3203 E_CAPTURE_CLK.n5 VSS 0.21407f
C3204 E_CAPTURE_CLK.t10 VSS 1.0142f
C3205 E_CAPTURE_CLK.n6 VSS 0.44291f
C3206 E_CAPTURE_CLK.t13 VSS 1.01912f
C3207 E_CAPTURE_CLK.t14 VSS 0.24367f
C3208 E_CAPTURE_CLK.t9 VSS 0.24367f
C3209 E_CAPTURE_CLK.n7 VSS 0.74055f
C3210 E_CAPTURE_CLK.n8 VSS 0.41736f
C3211 E_CAPTURE_CLK.t8 VSS 0.24367f
C3212 E_CAPTURE_CLK.t4 VSS 0.24367f
C3213 E_CAPTURE_CLK.n9 VSS 0.74055f
C3214 E_CAPTURE_CLK.n10 VSS 0.21957f
C3215 E_CAPTURE_CLK.t1 VSS 0.24367f
C3216 E_CAPTURE_CLK.t7 VSS 0.24367f
C3217 E_CAPTURE_CLK.n11 VSS 0.74055f
C3218 E_CAPTURE_CLK.n12 VSS 0.21957f
C3219 E_CAPTURE_CLK.t12 VSS 1.01241f
C3220 E_CAPTURE_CLK.n13 VSS 0.30032f
C3221 E_CAPTURE_CLK.n14 VSS 1.53504f
C3222 E_SENSE.t61 VSS 1.13059f
C3223 E_SENSE.t62 VSS 0.25814f
C3224 E_SENSE.t57 VSS 0.25814f
C3225 E_SENSE.n0 VSS 0.83775f
C3226 E_SENSE.n1 VSS 0.46048f
C3227 E_SENSE.t58 VSS 0.25814f
C3228 E_SENSE.t59 VSS 0.25814f
C3229 E_SENSE.n2 VSS 0.83775f
C3230 E_SENSE.n3 VSS 0.24038f
C3231 E_SENSE.t54 VSS 0.25814f
C3232 E_SENSE.t55 VSS 0.25814f
C3233 E_SENSE.n4 VSS 0.83775f
C3234 E_SENSE.n5 VSS 0.24038f
C3235 E_SENSE.t56 VSS 0.25814f
C3236 E_SENSE.t32 VSS 0.25814f
C3237 E_SENSE.n6 VSS 0.83775f
C3238 E_SENSE.n7 VSS 0.24038f
C3239 E_SENSE.t33 VSS 0.25814f
C3240 E_SENSE.t34 VSS 0.25814f
C3241 E_SENSE.n8 VSS 0.83775f
C3242 E_SENSE.n9 VSS 0.24038f
C3243 E_SENSE.t37 VSS 0.25814f
C3244 E_SENSE.t38 VSS 0.25814f
C3245 E_SENSE.n10 VSS 0.83775f
C3246 E_SENSE.n11 VSS 0.24038f
C3247 E_SENSE.t39 VSS 0.25814f
C3248 E_SENSE.t28 VSS 0.25814f
C3249 E_SENSE.n12 VSS 0.83775f
C3250 E_SENSE.n13 VSS 0.24038f
C3251 E_SENSE.t29 VSS 0.25814f
C3252 E_SENSE.t24 VSS 0.25814f
C3253 E_SENSE.n14 VSS 0.83775f
C3254 E_SENSE.n15 VSS 0.24038f
C3255 E_SENSE.t25 VSS 0.25814f
C3256 E_SENSE.t20 VSS 0.25814f
C3257 E_SENSE.n16 VSS 0.83775f
C3258 E_SENSE.n17 VSS 0.24038f
C3259 E_SENSE.t21 VSS 0.25814f
C3260 E_SENSE.t22 VSS 0.25814f
C3261 E_SENSE.n18 VSS 0.83775f
C3262 E_SENSE.n19 VSS 0.24038f
C3263 E_SENSE.t23 VSS 0.25814f
C3264 E_SENSE.t18 VSS 0.25814f
C3265 E_SENSE.n20 VSS 0.83775f
C3266 E_SENSE.n21 VSS 0.24038f
C3267 E_SENSE.t19 VSS 0.25814f
C3268 E_SENSE.t14 VSS 0.25814f
C3269 E_SENSE.n22 VSS 0.83775f
C3270 E_SENSE.n23 VSS 0.24038f
C3271 E_SENSE.t15 VSS 0.25814f
C3272 E_SENSE.t10 VSS 0.25814f
C3273 E_SENSE.n24 VSS 0.83775f
C3274 E_SENSE.n25 VSS 0.24038f
C3275 E_SENSE.t11 VSS 0.25814f
C3276 E_SENSE.t6 VSS 0.25814f
C3277 E_SENSE.n26 VSS 0.83775f
C3278 E_SENSE.n27 VSS 0.24038f
C3279 E_SENSE.t7 VSS 0.25814f
C3280 E_SENSE.t2 VSS 0.25814f
C3281 E_SENSE.n28 VSS 0.83775f
C3282 E_SENSE.n29 VSS 0.24038f
C3283 E_SENSE.t3 VSS 0.25814f
C3284 E_SENSE.t4 VSS 0.25814f
C3285 E_SENSE.n30 VSS 0.83775f
C3286 E_SENSE.n31 VSS 0.24038f
C3287 E_SENSE.t5 VSS 0.25814f
C3288 E_SENSE.t0 VSS 0.25814f
C3289 E_SENSE.n32 VSS 0.83775f
C3290 E_SENSE.n33 VSS 0.24038f
C3291 E_SENSE.t1 VSS 0.25814f
C3292 E_SENSE.t126 VSS 0.25814f
C3293 E_SENSE.n34 VSS 0.83775f
C3294 E_SENSE.n35 VSS 0.24038f
C3295 E_SENSE.t127 VSS 0.25814f
C3296 E_SENSE.t16 VSS 0.25814f
C3297 E_SENSE.n36 VSS 0.83775f
C3298 E_SENSE.n37 VSS 0.24038f
C3299 E_SENSE.t17 VSS 0.25814f
C3300 E_SENSE.t30 VSS 0.25814f
C3301 E_SENSE.n38 VSS 0.83775f
C3302 E_SENSE.n39 VSS 0.24038f
C3303 E_SENSE.t31 VSS 0.25814f
C3304 E_SENSE.t26 VSS 0.25814f
C3305 E_SENSE.n40 VSS 0.83775f
C3306 E_SENSE.n41 VSS 0.24038f
C3307 E_SENSE.t27 VSS 0.25814f
C3308 E_SENSE.t35 VSS 0.25814f
C3309 E_SENSE.n42 VSS 0.83775f
C3310 E_SENSE.n43 VSS 0.24038f
C3311 E_SENSE.t36 VSS 0.25814f
C3312 E_SENSE.t52 VSS 0.25814f
C3313 E_SENSE.n44 VSS 0.83775f
C3314 E_SENSE.n45 VSS 0.24038f
C3315 E_SENSE.t53 VSS 0.25814f
C3316 E_SENSE.t50 VSS 0.25814f
C3317 E_SENSE.n46 VSS 0.83775f
C3318 E_SENSE.n47 VSS 0.24038f
C3319 E_SENSE.t51 VSS 0.25814f
C3320 E_SENSE.t48 VSS 0.25814f
C3321 E_SENSE.n48 VSS 0.83775f
C3322 E_SENSE.n49 VSS 0.24038f
C3323 E_SENSE.t49 VSS 0.25814f
C3324 E_SENSE.t8 VSS 0.25814f
C3325 E_SENSE.n50 VSS 0.83775f
C3326 E_SENSE.n51 VSS 0.24038f
C3327 E_SENSE.t9 VSS 0.25814f
C3328 E_SENSE.t12 VSS 0.25814f
C3329 E_SENSE.n52 VSS 0.83775f
C3330 E_SENSE.n53 VSS 0.24038f
C3331 E_SENSE.t13 VSS 0.25814f
C3332 E_SENSE.t46 VSS 0.25814f
C3333 E_SENSE.n54 VSS 0.83775f
C3334 E_SENSE.n55 VSS 0.24038f
C3335 E_SENSE.t47 VSS 0.25814f
C3336 E_SENSE.t44 VSS 0.25814f
C3337 E_SENSE.n56 VSS 0.83775f
C3338 E_SENSE.n57 VSS 0.24038f
C3339 E_SENSE.t45 VSS 0.25814f
C3340 E_SENSE.t42 VSS 0.25814f
C3341 E_SENSE.n58 VSS 0.83775f
C3342 E_SENSE.n59 VSS 0.24038f
C3343 E_SENSE.t43 VSS 0.25814f
C3344 E_SENSE.t40 VSS 0.25814f
C3345 E_SENSE.n60 VSS 0.83775f
C3346 E_SENSE.n61 VSS 0.24038f
C3347 E_SENSE.t41 VSS 1.12307f
C3348 E_SENSE.n62 VSS 0.49734f
C3349 E_SENSE.t120 VSS 1.12859f
C3350 E_SENSE.t121 VSS 0.25814f
C3351 E_SENSE.t122 VSS 0.25814f
C3352 E_SENSE.n63 VSS 0.83157f
C3353 E_SENSE.n64 VSS 0.46866f
C3354 E_SENSE.t117 VSS 0.25814f
C3355 E_SENSE.t118 VSS 0.25814f
C3356 E_SENSE.n65 VSS 0.83157f
C3357 E_SENSE.n66 VSS 0.24656f
C3358 E_SENSE.t119 VSS 0.25814f
C3359 E_SENSE.t114 VSS 0.25814f
C3360 E_SENSE.n67 VSS 0.83157f
C3361 E_SENSE.n68 VSS 0.24656f
C3362 E_SENSE.t115 VSS 0.25814f
C3363 E_SENSE.t116 VSS 0.25814f
C3364 E_SENSE.n69 VSS 0.83157f
C3365 E_SENSE.n70 VSS 0.24656f
C3366 E_SENSE.t111 VSS 0.25814f
C3367 E_SENSE.t112 VSS 0.25814f
C3368 E_SENSE.n71 VSS 0.83157f
C3369 E_SENSE.n72 VSS 0.24656f
C3370 E_SENSE.t113 VSS 0.25814f
C3371 E_SENSE.t108 VSS 0.25814f
C3372 E_SENSE.n73 VSS 0.83157f
C3373 E_SENSE.n74 VSS 0.24656f
C3374 E_SENSE.t109 VSS 0.25814f
C3375 E_SENSE.t110 VSS 0.25814f
C3376 E_SENSE.n75 VSS 0.83157f
C3377 E_SENSE.n76 VSS 0.24656f
C3378 E_SENSE.t105 VSS 0.25814f
C3379 E_SENSE.t106 VSS 0.25814f
C3380 E_SENSE.n77 VSS 0.83157f
C3381 E_SENSE.n78 VSS 0.24656f
C3382 E_SENSE.t107 VSS 0.25814f
C3383 E_SENSE.t102 VSS 0.25814f
C3384 E_SENSE.n79 VSS 0.83157f
C3385 E_SENSE.n80 VSS 0.24656f
C3386 E_SENSE.t103 VSS 0.25814f
C3387 E_SENSE.t104 VSS 0.25814f
C3388 E_SENSE.n81 VSS 0.83157f
C3389 E_SENSE.n82 VSS 0.24656f
C3390 E_SENSE.t99 VSS 0.25814f
C3391 E_SENSE.t100 VSS 0.25814f
C3392 E_SENSE.n83 VSS 0.83157f
C3393 E_SENSE.n84 VSS 0.24656f
C3394 E_SENSE.t101 VSS 0.25814f
C3395 E_SENSE.t96 VSS 0.25814f
C3396 E_SENSE.n85 VSS 0.83157f
C3397 E_SENSE.n86 VSS 0.24656f
C3398 E_SENSE.t97 VSS 0.25814f
C3399 E_SENSE.t98 VSS 0.25814f
C3400 E_SENSE.n87 VSS 0.83157f
C3401 E_SENSE.n88 VSS 0.24656f
C3402 E_SENSE.t93 VSS 0.25814f
C3403 E_SENSE.t94 VSS 0.25814f
C3404 E_SENSE.n89 VSS 0.83157f
C3405 E_SENSE.n90 VSS 0.24656f
C3406 E_SENSE.t95 VSS 0.25814f
C3407 E_SENSE.t90 VSS 0.25814f
C3408 E_SENSE.n91 VSS 0.83157f
C3409 E_SENSE.n92 VSS 0.24656f
C3410 E_SENSE.t91 VSS 0.25814f
C3411 E_SENSE.t92 VSS 0.25814f
C3412 E_SENSE.n93 VSS 0.83157f
C3413 E_SENSE.n94 VSS 0.24656f
C3414 E_SENSE.t87 VSS 0.25814f
C3415 E_SENSE.t88 VSS 0.25814f
C3416 E_SENSE.n95 VSS 0.83157f
C3417 E_SENSE.n96 VSS 0.24656f
C3418 E_SENSE.t89 VSS 0.25814f
C3419 E_SENSE.t84 VSS 0.25814f
C3420 E_SENSE.n97 VSS 0.83157f
C3421 E_SENSE.n98 VSS 0.24656f
C3422 E_SENSE.t85 VSS 0.25814f
C3423 E_SENSE.t86 VSS 0.25814f
C3424 E_SENSE.n99 VSS 0.83157f
C3425 E_SENSE.n100 VSS 0.24656f
C3426 E_SENSE.t81 VSS 0.25814f
C3427 E_SENSE.t82 VSS 0.25814f
C3428 E_SENSE.n101 VSS 0.83157f
C3429 E_SENSE.n102 VSS 0.24656f
C3430 E_SENSE.t83 VSS 0.25814f
C3431 E_SENSE.t78 VSS 0.25814f
C3432 E_SENSE.n103 VSS 0.83157f
C3433 E_SENSE.n104 VSS 0.24656f
C3434 E_SENSE.t79 VSS 0.25814f
C3435 E_SENSE.t80 VSS 0.25814f
C3436 E_SENSE.n105 VSS 0.83157f
C3437 E_SENSE.n106 VSS 0.24656f
C3438 E_SENSE.t75 VSS 0.25814f
C3439 E_SENSE.t76 VSS 0.25814f
C3440 E_SENSE.n107 VSS 0.83157f
C3441 E_SENSE.n108 VSS 0.24656f
C3442 E_SENSE.t77 VSS 0.25814f
C3443 E_SENSE.t72 VSS 0.25814f
C3444 E_SENSE.n109 VSS 0.83157f
C3445 E_SENSE.n110 VSS 0.24656f
C3446 E_SENSE.t73 VSS 0.25814f
C3447 E_SENSE.t74 VSS 0.25814f
C3448 E_SENSE.n111 VSS 0.83157f
C3449 E_SENSE.n112 VSS 0.24656f
C3450 E_SENSE.t69 VSS 0.25814f
C3451 E_SENSE.t70 VSS 0.25814f
C3452 E_SENSE.n113 VSS 0.83157f
C3453 E_SENSE.n114 VSS 0.24656f
C3454 E_SENSE.t71 VSS 0.25814f
C3455 E_SENSE.t66 VSS 0.25814f
C3456 E_SENSE.n115 VSS 0.83157f
C3457 E_SENSE.n116 VSS 0.24656f
C3458 E_SENSE.t67 VSS 0.25814f
C3459 E_SENSE.t68 VSS 0.25814f
C3460 E_SENSE.n117 VSS 0.83157f
C3461 E_SENSE.n118 VSS 0.24656f
C3462 E_SENSE.t123 VSS 0.25814f
C3463 E_SENSE.t124 VSS 0.25814f
C3464 E_SENSE.n119 VSS 0.83157f
C3465 E_SENSE.n120 VSS 0.24656f
C3466 E_SENSE.t125 VSS 0.25814f
C3467 E_SENSE.t63 VSS 0.25814f
C3468 E_SENSE.n121 VSS 0.83157f
C3469 E_SENSE.n122 VSS 0.24656f
C3470 E_SENSE.t64 VSS 0.25814f
C3471 E_SENSE.t65 VSS 0.25814f
C3472 E_SENSE.n123 VSS 0.83157f
C3473 E_SENSE.n124 VSS 0.24656f
C3474 E_SENSE.t60 VSS 1.12106f
C3475 E_SENSE.n125 VSS 0.33723f
C3476 E_SENSE.n126 VSS 2.82207f
.ends
