* PEX produced using /foss/tools/sak/sak-pex.sh with m=3 and s=1 (extresist threshold=0 mOhm, minres=1 mOhm, mindelay=0 ps)
* NGSPICE file created from local_clock_fanout_pex.ext - technology: gf180mcuD

.subckt local_clock_fanout_pex CLKP_H CLKP_HB CLKN_H CLKN_HB VDD VSS E_SENSE E_CAPTURE_CLK
+ E_CAPTURE_CLKB O_SENSE O_CAPTURE_CLK O_CAPTURE_CLKB
X0 VSS.t79 a_2700_41600.t11 O_CAPTURE_CLKB.t3 VSS.t78 nfet_03v3 ad=2.08p pd=8.52u as=2.08p ps=8.52u w=8u l=0.28u
X1 VDD.t135 a_14220_41600.t33 O_SENSE.t20 VDD.t134 pfet_03v3 ad=2.08p pd=8.52u as=2.08p ps=8.52u w=8u l=0.28u
X2 O_CAPTURE_CLK.t9 a_4812_41600.t14 VSS.t63 VSS.t62 nfet_03v3 ad=2.08p pd=8.52u as=2.08p ps=8.52u w=8u l=0.28u
X3 VDD.t167 a_2700_41600.t17 O_CAPTURE_CLKB.t11 VDD.t166 pfet_03v3 ad=2.08p pd=8.52u as=2.08p ps=8.52u w=8u l=0.28u
X4 O_CAPTURE_CLKB.t15 a_2700_41600.t8 VSS.t189 VSS.t188 nfet_03v3 ad=3.52p pd=16.88u as=2.08p ps=8.52u w=8u l=0.28u
X5 VSS.t73 a_4812_6400.t13 E_CAPTURE_CLK.t7 VSS.t72 nfet_03v3 ad=2.08p pd=8.52u as=2.08p ps=8.52u w=8u l=0.28u
X6 a_6924_6400.t1 CLKP_HB.t6 VDD.t175 VDD.t174 pfet_03v3 ad=3.52p pd=16.88u as=2.08p ps=8.52u w=8u l=0.28u
X7 VSS.t133 a_14220_41600.t25 O_SENSE.t18 VSS.t132 nfet_03v3 ad=2.08p pd=8.52u as=2.08p ps=8.52u w=8u l=0.28u
X8 VDD.t53 a_14220_41600.t39 O_SENSE.t5 VDD.t52 pfet_03v3 ad=2.08p pd=8.52u as=2.08p ps=8.52u w=8u l=0.28u
X9 VSS.t1 a_14220_6400.t23 E_SENSE.t4 VSS.t0 nfet_03v3 ad=2.08p pd=8.52u as=2.08p ps=8.52u w=8u l=0.28u
X10 VSS.t47 a_4812_6400.t11 E_CAPTURE_CLK.t5 VSS.t46 nfet_03v3 ad=2.08p pd=8.52u as=2.08p ps=8.52u w=8u l=0.28u
X11 E_SENSE.t1 a_14220_6400.t42 VDD.t3 VDD.t2 pfet_03v3 ad=2.08p pd=8.52u as=2.08p ps=8.52u w=8u l=0.28u
X12 E_SENSE.t8 a_14220_6400.t40 VDD.t23 VDD.t22 pfet_03v3 ad=2.08p pd=8.52u as=2.08p ps=8.52u w=8u l=0.28u
X13 E_CAPTURE_CLKB.t15 a_2700_6400.t14 VSS.t199 VSS.t198 nfet_03v3 ad=2.08p pd=8.52u as=2.08p ps=8.52u w=8u l=0.28u
X14 O_SENSE.t23 a_14220_41600.t22 VSS.t139 VSS.t138 nfet_03v3 ad=2.08p pd=8.52u as=2.08p ps=8.52u w=8u l=0.28u
X15 E_CAPTURE_CLK.t8 a_4812_6400.t14 VSS.t81 VSS.t80 nfet_03v3 ad=2.08p pd=8.52u as=2.08p ps=8.52u w=8u l=0.28u
X16 VDD.t181 CLKP_HB.t7 a_6924_6400.t0 VDD.t180 pfet_03v3 ad=2.08p pd=8.52u as=3.52p ps=16.88u w=8u l=0.28u
X17 O_SENSE.t11 a_14220_41600.t36 VDD.t107 VDD.t106 pfet_03v3 ad=2.08p pd=8.52u as=2.08p ps=8.52u w=8u l=0.28u
X18 O_CAPTURE_CLKB.t0 a_2700_41600.t14 VSS.t27 VSS.t26 nfet_03v3 ad=2.08p pd=8.52u as=2.08p ps=8.52u w=8u l=0.28u
X19 E_CAPTURE_CLKB.t13 a_2700_6400.t12 VSS.t183 VSS.t182 nfet_03v3 ad=2.08p pd=8.52u as=2.08p ps=8.52u w=8u l=0.28u
X20 VSS.t125 a_14220_41600.t31 O_SENSE.t12 VSS.t124 nfet_03v3 ad=2.08p pd=8.52u as=3.52p ps=16.88u w=8u l=0.28u
X21 E_CAPTURE_CLK.t6 a_4812_6400.t12 VSS.t71 VSS.t70 nfet_03v3 ad=2.08p pd=8.52u as=2.08p ps=8.52u w=8u l=0.28u
X22 VDD.t37 a_14220_6400.t43 E_SENSE.t14 VDD.t36 pfet_03v3 ad=2.08p pd=8.52u as=2.08p ps=8.52u w=8u l=0.28u
X23 VDD.t141 a_4812_6400.t23 E_CAPTURE_CLK.t13 VDD.t140 pfet_03v3 ad=2.08p pd=8.52u as=3.52p ps=16.88u w=8u l=0.28u
X24 VDD.t1 a_14220_6400.t41 E_SENSE.t0 VDD.t0 pfet_03v3 ad=2.08p pd=8.52u as=2.08p ps=8.52u w=8u l=0.28u
X25 VDD.t129 a_14220_41600.t45 O_SENSE.t16 VDD.t128 pfet_03v3 ad=2.08p pd=8.52u as=2.08p ps=8.52u w=8u l=0.28u
X26 a_14220_41600.t4 a_6924_41600.t6 VSS.t57 VSS.t56 nfet_03v3 ad=2.08p pd=8.52u as=2.08p ps=8.52u w=8u l=0.28u
X27 VSS.t103 a_2700_6400.t15 E_CAPTURE_CLKB.t5 VSS.t102 nfet_03v3 ad=2.08p pd=8.52u as=3.52p ps=16.88u w=8u l=0.28u
X28 E_SENSE.t13 a_14220_6400.t16 VSS.t37 VSS.t36 nfet_03v3 ad=3.52p pd=16.88u as=2.08p ps=8.52u w=8u l=0.28u
X29 VSS.t197 a_2700_6400.t13 E_CAPTURE_CLKB.t14 VSS.t196 nfet_03v3 ad=2.08p pd=8.52u as=2.08p ps=8.52u w=8u l=0.28u
X30 VDD.t41 a_14220_6400.t35 E_SENSE.t16 VDD.t40 pfet_03v3 ad=2.08p pd=8.52u as=2.08p ps=8.52u w=8u l=0.28u
X31 a_14220_41600.t9 a_6924_41600.t12 VDD.t147 VDD.t146 pfet_03v3 ad=3.52p pd=16.88u as=2.08p ps=8.52u w=8u l=0.28u
X32 O_SENSE.t15 a_14220_41600.t28 VSS.t131 VSS.t130 nfet_03v3 ad=2.08p pd=8.52u as=2.08p ps=8.52u w=8u l=0.28u
X33 O_SENSE.t29 a_14220_41600.t42 VDD.t199 VDD.t198 pfet_03v3 ad=2.08p pd=8.52u as=2.08p ps=8.52u w=8u l=0.28u
X34 O_CAPTURE_CLK.t3 a_4812_41600.t12 VSS.t21 VSS.t20 nfet_03v3 ad=2.08p pd=8.52u as=2.08p ps=8.52u w=8u l=0.28u
X35 O_CAPTURE_CLK.t1 a_4812_41600.t18 VDD.t17 VDD.t16 pfet_03v3 ad=2.08p pd=8.52u as=2.08p ps=8.52u w=8u l=0.28u
X36 VSS.t151 a_14220_6400.t17 E_SENSE.t30 VSS.t150 nfet_03v3 ad=2.08p pd=8.52u as=2.08p ps=8.52u w=8u l=0.28u
X37 E_SENSE.t17 a_14220_6400.t36 VDD.t43 VDD.t42 pfet_03v3 ad=2.08p pd=8.52u as=2.08p ps=8.52u w=8u l=0.28u
X38 E_CAPTURE_CLK.t0 a_4812_6400.t16 VDD.t9 VDD.t8 pfet_03v3 ad=3.52p pd=16.88u as=2.08p ps=8.52u w=8u l=0.28u
X39 a_4812_41600.t5 CLKN_H.t2 VSS.t175 VSS.t174 nfet_03v3 ad=2.08p pd=8.52u as=2.08p ps=8.52u w=8u l=0.28u
X40 a_14220_41600.t7 a_6924_41600.t18 VDD.t143 VDD.t142 pfet_03v3 ad=2.08p pd=8.52u as=2.08p ps=8.52u w=8u l=0.28u
X41 VSS.t65 a_4812_41600.t9 O_CAPTURE_CLK.t10 VSS.t64 nfet_03v3 ad=2.08p pd=8.52u as=2.08p ps=8.52u w=8u l=0.28u
X42 E_SENSE.t3 a_14220_6400.t34 VDD.t7 VDD.t6 pfet_03v3 ad=2.08p pd=8.52u as=2.08p ps=8.52u w=8u l=0.28u
X43 a_4812_41600.t3 CLKN_H.t4 VDD.t195 VDD.t194 pfet_03v3 ad=3.52p pd=16.88u as=2.08p ps=8.52u w=8u l=0.28u
X44 E_CAPTURE_CLKB.t2 a_2700_6400.t8 VSS.t49 VSS.t48 nfet_03v3 ad=3.52p pd=16.88u as=2.08p ps=8.52u w=8u l=0.28u
X45 VSS.t115 CLKN_HB.t3 a_2700_41600.t6 VSS.t114 nfet_03v3 ad=2.08p pd=8.52u as=2.08p ps=8.52u w=8u l=0.28u
X46 a_6924_41600.t3 CLKN_HB.t0 VSS.t105 VSS.t104 nfet_03v3 ad=3.52p pd=16.88u as=2.08p ps=8.52u w=8u l=0.28u
X47 VDD.t69 a_2700_6400.t17 E_CAPTURE_CLKB.t3 VDD.t68 pfet_03v3 ad=2.08p pd=8.52u as=2.08p ps=8.52u w=8u l=0.28u
X48 VSS.t17 a_6924_41600.t9 a_14220_41600.t0 VSS.t16 nfet_03v3 ad=2.08p pd=8.52u as=2.08p ps=8.52u w=8u l=0.28u
X49 a_2700_6400.t5 CLKP_HB.t4 VSS.t163 VSS.t162 nfet_03v3 ad=2.08p pd=8.52u as=2.08p ps=8.52u w=8u l=0.28u
X50 VDD.t11 a_4812_6400.t17 E_CAPTURE_CLK.t1 VDD.t10 pfet_03v3 ad=2.08p pd=8.52u as=2.08p ps=8.52u w=8u l=0.28u
X51 VDD.t163 a_6924_41600.t15 a_14220_41600.t15 VDD.t162 pfet_03v3 ad=2.08p pd=8.52u as=2.08p ps=8.52u w=8u l=0.28u
X52 VDD.t177 CLKP_HB.t11 a_2700_6400.t0 VDD.t176 pfet_03v3 ad=2.08p pd=8.52u as=3.52p ps=16.88u w=8u l=0.28u
X53 a_14220_6400.t14 a_6924_6400.t8 VSS.t149 VSS.t148 nfet_03v3 ad=2.08p pd=8.52u as=2.08p ps=8.52u w=8u l=0.28u
X54 a_2700_6400.t7 CLKP_HB.t2 VSS.t155 VSS.t154 nfet_03v3 ad=3.52p pd=16.88u as=2.08p ps=8.52u w=8u l=0.28u
X55 O_CAPTURE_CLKB.t4 a_2700_41600.t12 VSS.t87 VSS.t86 nfet_03v3 ad=2.08p pd=8.52u as=2.08p ps=8.52u w=8u l=0.28u
X56 O_SENSE.t21 a_14220_41600.t34 VDD.t137 VDD.t136 pfet_03v3 ad=2.08p pd=8.52u as=2.08p ps=8.52u w=8u l=0.28u
X57 VSS.t127 a_4812_41600.t15 O_CAPTURE_CLK.t14 VSS.t126 nfet_03v3 ad=2.08p pd=8.52u as=3.52p ps=16.88u w=8u l=0.28u
X58 a_4812_6400.t7 CLKP_H.t0 VSS.t123 VSS.t122 nfet_03v3 ad=3.52p pd=16.88u as=2.08p ps=8.52u w=8u l=0.28u
X59 E_CAPTURE_CLKB.t4 a_2700_6400.t18 VDD.t71 VDD.t70 pfet_03v3 ad=2.08p pd=8.52u as=2.08p ps=8.52u w=8u l=0.28u
X60 VDD.t109 a_4812_41600.t21 O_CAPTURE_CLK.t12 VDD.t108 pfet_03v3 ad=2.08p pd=8.52u as=2.08p ps=8.52u w=8u l=0.28u
X61 VSS.t13 a_14220_41600.t17 O_SENSE.t1 VSS.t12 nfet_03v3 ad=2.08p pd=8.52u as=2.08p ps=8.52u w=8u l=0.28u
X62 VSS.t171 a_2700_41600.t9 O_CAPTURE_CLKB.t14 VSS.t170 nfet_03v3 ad=2.08p pd=8.52u as=2.08p ps=8.52u w=8u l=0.28u
X63 VSS.t5 a_6924_6400.t9 a_14220_6400.t0 VSS.t4 nfet_03v3 ad=2.08p pd=8.52u as=2.08p ps=8.52u w=8u l=0.28u
X64 VSS.t165 CLKP_HB.t3 a_2700_6400.t6 VSS.t164 nfet_03v3 ad=2.08p pd=8.52u as=2.08p ps=8.52u w=8u l=0.28u
X65 VSS.t119 CLKP_H.t3 a_4812_6400.t4 VSS.t118 nfet_03v3 ad=2.08p pd=8.52u as=3.52p ps=16.88u w=8u l=0.28u
X66 a_14220_6400.t10 a_6924_6400.t18 VDD.t79 VDD.t78 pfet_03v3 ad=2.08p pd=8.52u as=2.08p ps=8.52u w=8u l=0.28u
X67 O_SENSE.t6 a_14220_41600.t40 VDD.t55 VDD.t54 pfet_03v3 ad=2.08p pd=8.52u as=2.08p ps=8.52u w=8u l=0.28u
X68 VSS.t117 CLKP_H.t1 a_4812_6400.t6 VSS.t116 nfet_03v3 ad=2.08p pd=8.52u as=2.08p ps=8.52u w=8u l=0.28u
X69 VSS.t31 a_14220_6400.t31 E_SENSE.t9 VSS.t30 nfet_03v3 ad=2.08p pd=8.52u as=3.52p ps=16.88u w=8u l=0.28u
X70 a_4812_6400.t1 CLKP_H.t6 VDD.t117 VDD.t116 pfet_03v3 ad=2.08p pd=8.52u as=2.08p ps=8.52u w=8u l=0.28u
X71 a_2700_41600.t1 CLKN_HB.t10 VDD.t89 VDD.t88 pfet_03v3 ad=2.08p pd=8.52u as=2.08p ps=8.52u w=8u l=0.28u
X72 VSS.t191 a_14220_41600.t23 O_SENSE.t30 VSS.t190 nfet_03v3 ad=2.08p pd=8.52u as=2.08p ps=8.52u w=8u l=0.28u
X73 VDD.t103 a_6924_6400.t19 a_14220_6400.t11 VDD.t102 pfet_03v3 ad=2.08p pd=8.52u as=3.52p ps=16.88u w=8u l=0.28u
X74 VDD.t31 a_14220_41600.t37 O_SENSE.t3 VDD.t30 pfet_03v3 ad=2.08p pd=8.52u as=2.08p ps=8.52u w=8u l=0.28u
X75 O_SENSE.t25 a_14220_41600.t20 VSS.t169 VSS.t168 nfet_03v3 ad=2.08p pd=8.52u as=2.08p ps=8.52u w=8u l=0.28u
X76 a_6924_6400.t3 CLKP_HB.t0 VSS.t157 VSS.t156 nfet_03v3 ad=3.52p pd=16.88u as=2.08p ps=8.52u w=8u l=0.28u
X77 E_SENSE.t19 a_14220_6400.t26 VSS.t53 VSS.t52 nfet_03v3 ad=2.08p pd=8.52u as=2.08p ps=8.52u w=8u l=0.28u
X78 VDD.t45 a_6924_41600.t13 a_14220_41600.t3 VDD.t44 pfet_03v3 ad=2.08p pd=8.52u as=2.08p ps=8.52u w=8u l=0.28u
X79 VSS.t185 a_14220_41600.t29 O_SENSE.t26 VSS.t184 nfet_03v3 ad=2.08p pd=8.52u as=2.08p ps=8.52u w=8u l=0.28u
X80 E_SENSE.t5 a_14220_6400.t24 VSS.t3 VSS.t2 nfet_03v3 ad=2.08p pd=8.52u as=2.08p ps=8.52u w=8u l=0.28u
X81 a_14220_41600.t5 a_6924_41600.t4 VSS.t59 VSS.t58 nfet_03v3 ad=3.52p pd=16.88u as=2.08p ps=8.52u w=8u l=0.28u
X82 VDD.t47 a_4812_41600.t19 O_CAPTURE_CLK.t6 VDD.t46 pfet_03v3 ad=2.08p pd=8.52u as=2.08p ps=8.52u w=8u l=0.28u
X83 VSS.t159 CLKP_HB.t1 a_6924_6400.t2 VSS.t158 nfet_03v3 ad=2.08p pd=8.52u as=3.52p ps=16.88u w=8u l=0.28u
X84 a_14220_6400.t5 a_6924_6400.t12 VDD.t51 VDD.t50 pfet_03v3 ad=3.52p pd=16.88u as=2.08p ps=8.52u w=8u l=0.28u
X85 O_SENSE.t19 a_14220_41600.t26 VSS.t135 VSS.t134 nfet_03v3 ad=2.08p pd=8.52u as=2.08p ps=8.52u w=8u l=0.28u
X86 VSS.t99 a_14220_6400.t27 E_SENSE.t28 VSS.t98 nfet_03v3 ad=2.08p pd=8.52u as=2.08p ps=8.52u w=8u l=0.28u
X87 VSS.t83 a_4812_6400.t15 E_CAPTURE_CLK.t9 VSS.t82 nfet_03v3 ad=2.08p pd=8.52u as=3.52p ps=16.88u w=8u l=0.28u
X88 O_CAPTURE_CLK.t11 a_4812_41600.t10 VSS.t67 VSS.t66 nfet_03v3 ad=2.08p pd=8.52u as=2.08p ps=8.52u w=8u l=0.28u
X89 VSS.t51 a_14220_6400.t25 E_SENSE.t18 VSS.t50 nfet_03v3 ad=2.08p pd=8.52u as=2.08p ps=8.52u w=8u l=0.28u
X90 E_SENSE.t15 a_14220_6400.t44 VDD.t39 VDD.t38 pfet_03v3 ad=2.08p pd=8.52u as=2.08p ps=8.52u w=8u l=0.28u
X91 O_CAPTURE_CLK.t15 a_4812_41600.t16 VDD.t127 VDD.t126 pfet_03v3 ad=3.52p pd=16.88u as=2.08p ps=8.52u w=8u l=0.28u
X92 VSS.t95 a_14220_6400.t19 E_SENSE.t26 VSS.t94 nfet_03v3 ad=2.08p pd=8.52u as=2.08p ps=8.52u w=8u l=0.28u
X93 a_2700_41600.t3 CLKN_HB.t8 VDD.t83 VDD.t82 pfet_03v3 ad=3.52p pd=16.88u as=2.08p ps=8.52u w=8u l=0.28u
X94 VDD.t97 a_2700_41600.t23 O_CAPTURE_CLKB.t7 VDD.t96 pfet_03v3 ad=2.08p pd=8.52u as=3.52p ps=16.88u w=8u l=0.28u
X95 a_4812_41600.t7 CLKN_H.t0 VSS.t179 VSS.t178 nfet_03v3 ad=3.52p pd=16.88u as=2.08p ps=8.52u w=8u l=0.28u
X96 a_14220_41600.t13 a_6924_41600.t10 VSS.t147 VSS.t146 nfet_03v3 ad=2.08p pd=8.52u as=2.08p ps=8.52u w=8u l=0.28u
X97 a_14220_41600.t11 a_6924_41600.t16 VDD.t157 VDD.t156 pfet_03v3 ad=2.08p pd=8.52u as=2.08p ps=8.52u w=8u l=0.28u
X98 VSS.t25 a_6924_41600.t7 a_14220_41600.t1 VSS.t24 nfet_03v3 ad=2.08p pd=8.52u as=2.08p ps=8.52u w=8u l=0.28u
X99 E_SENSE.t27 a_14220_6400.t20 VSS.t97 VSS.t96 nfet_03v3 ad=2.08p pd=8.52u as=2.08p ps=8.52u w=8u l=0.28u
X100 E_CAPTURE_CLK.t2 a_4812_6400.t8 VSS.t9 VSS.t8 nfet_03v3 ad=3.52p pd=16.88u as=2.08p ps=8.52u w=8u l=0.28u
X101 O_SENSE.t2 a_14220_41600.t18 VSS.t15 VSS.t14 nfet_03v3 ad=2.08p pd=8.52u as=2.08p ps=8.52u w=8u l=0.28u
X102 E_SENSE.t31 a_14220_6400.t18 VSS.t153 VSS.t152 nfet_03v3 ad=2.08p pd=8.52u as=2.08p ps=8.52u w=8u l=0.28u
X103 VDD.t65 a_14220_6400.t37 E_SENSE.t22 VDD.t64 pfet_03v3 ad=2.08p pd=8.52u as=2.08p ps=8.52u w=8u l=0.28u
X104 O_SENSE.t13 a_14220_41600.t32 VDD.t125 VDD.t124 pfet_03v3 ad=3.52p pd=16.88u as=2.08p ps=8.52u w=8u l=0.28u
X105 VSS.t61 a_4812_41600.t13 O_CAPTURE_CLK.t8 VSS.t60 nfet_03v3 ad=2.08p pd=8.52u as=2.08p ps=8.52u w=8u l=0.28u
X106 VSS.t143 a_2700_6400.t9 E_CAPTURE_CLKB.t8 VSS.t142 nfet_03v3 ad=2.08p pd=8.52u as=2.08p ps=8.52u w=8u l=0.28u
X107 VSS.t11 a_4812_6400.t9 E_CAPTURE_CLK.t3 VSS.t10 nfet_03v3 ad=2.08p pd=8.52u as=2.08p ps=8.52u w=8u l=0.28u
X108 VSS.t161 CLKP_HB.t5 a_2700_6400.t4 VSS.t160 nfet_03v3 ad=2.08p pd=8.52u as=3.52p ps=16.88u w=8u l=0.28u
X109 E_SENSE.t23 a_14220_6400.t38 VDD.t67 VDD.t66 pfet_03v3 ad=2.08p pd=8.52u as=2.08p ps=8.52u w=8u l=0.28u
X110 E_CAPTURE_CLK.t14 a_4812_6400.t18 VDD.t153 VDD.t152 pfet_03v3 ad=2.08p pd=8.52u as=2.08p ps=8.52u w=8u l=0.28u
X111 VDD.t87 CLKN_HB.t11 a_2700_41600.t0 VDD.t86 pfet_03v3 ad=2.08p pd=8.52u as=3.52p ps=16.88u w=8u l=0.28u
X112 O_SENSE.t31 a_14220_41600.t24 VSS.t193 VSS.t192 nfet_03v3 ad=2.08p pd=8.52u as=2.08p ps=8.52u w=8u l=0.28u
X113 VDD.t85 CLKN_HB.t7 a_6924_41600.t0 VDD.t84 pfet_03v3 ad=2.08p pd=8.52u as=3.52p ps=16.88u w=8u l=0.28u
X114 a_2700_41600.t5 CLKN_HB.t4 VSS.t113 VSS.t112 nfet_03v3 ad=2.08p pd=8.52u as=2.08p ps=8.52u w=8u l=0.28u
X115 E_CAPTURE_CLKB.t9 a_2700_6400.t10 VSS.t145 VSS.t144 nfet_03v3 ad=2.08p pd=8.52u as=2.08p ps=8.52u w=8u l=0.28u
X116 VDD.t27 a_2700_6400.t19 E_CAPTURE_CLKB.t0 VDD.t26 pfet_03v3 ad=2.08p pd=8.52u as=2.08p ps=8.52u w=8u l=0.28u
X117 VSS.t137 a_14220_41600.t21 O_SENSE.t22 VSS.t136 nfet_03v3 ad=2.08p pd=8.52u as=2.08p ps=8.52u w=8u l=0.28u
X118 VDD.t101 a_2700_41600.t21 O_CAPTURE_CLKB.t9 VDD.t100 pfet_03v3 ad=2.08p pd=8.52u as=2.08p ps=8.52u w=8u l=0.28u
X119 a_14220_6400.t4 a_6924_6400.t10 VSS.t43 VSS.t42 nfet_03v3 ad=2.08p pd=8.52u as=2.08p ps=8.52u w=8u l=0.28u
X120 VDD.t105 a_14220_41600.t35 O_SENSE.t10 VDD.t104 pfet_03v3 ad=2.08p pd=8.52u as=2.08p ps=8.52u w=8u l=0.28u
X121 a_4812_6400.t5 CLKP_H.t2 VSS.t121 VSS.t120 nfet_03v3 ad=2.08p pd=8.52u as=2.08p ps=8.52u w=8u l=0.28u
X122 O_CAPTURE_CLKB.t12 a_2700_41600.t18 VDD.t169 VDD.t168 pfet_03v3 ad=2.08p pd=8.52u as=2.08p ps=8.52u w=8u l=0.28u
X123 VSS.t55 a_6924_41600.t5 a_14220_41600.t2 VSS.t54 nfet_03v3 ad=2.08p pd=8.52u as=2.08p ps=8.52u w=8u l=0.28u
X124 VSS.t69 a_6924_6400.t11 a_14220_6400.t6 VSS.t68 nfet_03v3 ad=2.08p pd=8.52u as=3.52p ps=16.88u w=8u l=0.28u
X125 VSS.t19 a_4812_41600.t11 O_CAPTURE_CLK.t2 VSS.t18 nfet_03v3 ad=2.08p pd=8.52u as=2.08p ps=8.52u w=8u l=0.28u
X126 VDD.t191 CLKN_H.t7 a_4812_41600.t0 VDD.t190 pfet_03v3 ad=2.08p pd=8.52u as=3.52p ps=16.88u w=8u l=0.28u
X127 O_CAPTURE_CLK.t4 a_4812_41600.t8 VSS.t23 VSS.t22 nfet_03v3 ad=3.52p pd=16.88u as=2.08p ps=8.52u w=8u l=0.28u
X128 a_2700_41600.t7 CLKN_HB.t2 VSS.t107 VSS.t106 nfet_03v3 ad=3.52p pd=16.88u as=2.08p ps=8.52u w=8u l=0.28u
X129 VSS.t29 a_2700_41600.t15 O_CAPTURE_CLKB.t1 VSS.t28 nfet_03v3 ad=2.08p pd=8.52u as=3.52p ps=16.88u w=8u l=0.28u
X130 a_14220_6400.t1 a_6924_6400.t4 VSS.t7 VSS.t6 nfet_03v3 ad=3.52p pd=16.88u as=2.08p ps=8.52u w=8u l=0.28u
X131 VDD.t149 a_6924_6400.t15 a_14220_6400.t12 VDD.t148 pfet_03v3 ad=2.08p pd=8.52u as=2.08p ps=8.52u w=8u l=0.28u
X132 a_14220_41600.t6 a_6924_41600.t8 VSS.t75 VSS.t74 nfet_03v3 ad=2.08p pd=8.52u as=2.08p ps=8.52u w=8u l=0.28u
X133 VDD.t73 a_6924_6400.t13 a_14220_6400.t7 VDD.t72 pfet_03v3 ad=2.08p pd=8.52u as=2.08p ps=8.52u w=8u l=0.28u
X134 O_SENSE.t17 a_14220_41600.t46 VDD.t131 VDD.t130 pfet_03v3 ad=2.08p pd=8.52u as=2.08p ps=8.52u w=8u l=0.28u
X135 E_SENSE.t29 a_14220_6400.t28 VSS.t101 VSS.t100 nfet_03v3 ad=2.08p pd=8.52u as=2.08p ps=8.52u w=8u l=0.28u
X136 VDD.t61 a_14220_6400.t45 E_SENSE.t20 VDD.t60 pfet_03v3 ad=2.08p pd=8.52u as=2.08p ps=8.52u w=8u l=0.28u
X137 a_14220_6400.t8 a_6924_6400.t14 VDD.t75 VDD.t74 pfet_03v3 ad=2.08p pd=8.52u as=2.08p ps=8.52u w=8u l=0.28u
X138 VDD.t57 a_14220_41600.t43 O_SENSE.t7 VDD.t56 pfet_03v3 ad=2.08p pd=8.52u as=2.08p ps=8.52u w=8u l=0.28u
X139 O_SENSE.t9 a_14220_41600.t16 VSS.t85 VSS.t84 nfet_03v3 ad=3.52p pd=16.88u as=2.08p ps=8.52u w=8u l=0.28u
X140 E_SENSE.t21 a_14220_6400.t46 VDD.t63 VDD.t62 pfet_03v3 ad=2.08p pd=8.52u as=2.08p ps=8.52u w=8u l=0.28u
X141 VSS.t111 CLKN_HB.t5 a_2700_41600.t4 VSS.t110 nfet_03v3 ad=2.08p pd=8.52u as=3.52p ps=16.88u w=8u l=0.28u
X142 VDD.t189 CLKN_H.t5 a_4812_41600.t2 VDD.t188 pfet_03v3 ad=2.08p pd=8.52u as=2.08p ps=8.52u w=8u l=0.28u
X143 VDD.t145 a_6924_41600.t19 a_14220_41600.t8 VDD.t144 pfet_03v3 ad=2.08p pd=8.52u as=3.52p ps=16.88u w=8u l=0.28u
X144 VSS.t33 a_14220_6400.t21 E_SENSE.t11 VSS.t32 nfet_03v3 ad=2.08p pd=8.52u as=2.08p ps=8.52u w=8u l=0.28u
X145 VSS.t109 CLKN_HB.t1 a_6924_41600.t2 VSS.t108 nfet_03v3 ad=2.08p pd=8.52u as=3.52p ps=16.88u w=8u l=0.28u
X146 VSS.t89 a_2700_41600.t13 O_CAPTURE_CLKB.t5 VSS.t88 nfet_03v3 ad=2.08p pd=8.52u as=2.08p ps=8.52u w=8u l=0.28u
X147 VSS.t167 a_14220_41600.t19 O_SENSE.t24 VSS.t166 nfet_03v3 ad=2.08p pd=8.52u as=2.08p ps=8.52u w=8u l=0.28u
X148 E_SENSE.t12 a_14220_6400.t22 VSS.t35 VSS.t34 nfet_03v3 ad=2.08p pd=8.52u as=2.08p ps=8.52u w=8u l=0.28u
X149 E_CAPTURE_CLK.t4 a_4812_6400.t10 VSS.t45 VSS.t44 nfet_03v3 ad=2.08p pd=8.52u as=2.08p ps=8.52u w=8u l=0.28u
X150 VDD.t123 a_4812_6400.t21 E_CAPTURE_CLK.t11 VDD.t122 pfet_03v3 ad=2.08p pd=8.52u as=2.08p ps=8.52u w=8u l=0.28u
X151 VDD.t171 a_2700_41600.t19 O_CAPTURE_CLKB.t13 VDD.t170 pfet_03v3 ad=2.08p pd=8.52u as=2.08p ps=8.52u w=8u l=0.28u
X152 VDD.t21 a_14220_6400.t39 E_SENSE.t7 VDD.t20 pfet_03v3 ad=2.08p pd=8.52u as=2.08p ps=8.52u w=8u l=0.28u
X153 VDD.t155 a_4812_6400.t19 E_CAPTURE_CLK.t15 VDD.t154 pfet_03v3 ad=2.08p pd=8.52u as=2.08p ps=8.52u w=8u l=0.28u
X154 O_CAPTURE_CLK.t13 a_4812_41600.t22 VDD.t111 VDD.t110 pfet_03v3 ad=2.08p pd=8.52u as=2.08p ps=8.52u w=8u l=0.28u
X155 O_CAPTURE_CLKB.t2 a_2700_41600.t10 VSS.t77 VSS.t76 nfet_03v3 ad=2.08p pd=8.52u as=2.08p ps=8.52u w=8u l=0.28u
X156 VSS.t181 a_2700_6400.t11 E_CAPTURE_CLKB.t12 VSS.t180 nfet_03v3 ad=2.08p pd=8.52u as=2.08p ps=8.52u w=8u l=0.28u
X157 E_CAPTURE_CLKB.t11 a_2700_6400.t22 VDD.t187 VDD.t186 pfet_03v3 ad=2.08p pd=8.52u as=2.08p ps=8.52u w=8u l=0.28u
X158 O_CAPTURE_CLKB.t10 a_2700_41600.t16 VDD.t165 VDD.t164 pfet_03v3 ad=3.52p pd=16.88u as=2.08p ps=8.52u w=8u l=0.28u
X159 E_CAPTURE_CLK.t12 a_4812_6400.t22 VDD.t139 VDD.t138 pfet_03v3 ad=2.08p pd=8.52u as=2.08p ps=8.52u w=8u l=0.28u
X160 E_CAPTURE_CLKB.t1 a_2700_6400.t20 VDD.t29 VDD.t28 pfet_03v3 ad=2.08p pd=8.52u as=2.08p ps=8.52u w=8u l=0.28u
X161 VDD.t197 a_14220_41600.t41 O_SENSE.t28 VDD.t196 pfet_03v3 ad=2.08p pd=8.52u as=2.08p ps=8.52u w=8u l=0.28u
X162 E_CAPTURE_CLK.t10 a_4812_6400.t20 VDD.t121 VDD.t120 pfet_03v3 ad=2.08p pd=8.52u as=2.08p ps=8.52u w=8u l=0.28u
X163 VSS.t173 CLKN_H.t3 a_4812_41600.t4 VSS.t172 nfet_03v3 ad=2.08p pd=8.52u as=3.52p ps=16.88u w=8u l=0.28u
X164 VDD.t133 a_2700_6400.t23 E_CAPTURE_CLKB.t7 VDD.t132 pfet_03v3 ad=2.08p pd=8.52u as=3.52p ps=16.88u w=8u l=0.28u
X165 O_SENSE.t4 a_14220_41600.t38 VDD.t33 VDD.t32 pfet_03v3 ad=2.08p pd=8.52u as=2.08p ps=8.52u w=8u l=0.28u
X166 E_SENSE.t10 a_14220_6400.t32 VDD.t25 VDD.t24 pfet_03v3 ad=3.52p pd=16.88u as=2.08p ps=8.52u w=8u l=0.28u
X167 VDD.t185 a_2700_6400.t21 E_CAPTURE_CLKB.t10 VDD.t184 pfet_03v3 ad=2.08p pd=8.52u as=2.08p ps=8.52u w=8u l=0.28u
X168 O_CAPTURE_CLKB.t6 a_2700_41600.t22 VDD.t95 VDD.t94 pfet_03v3 ad=2.08p pd=8.52u as=2.08p ps=8.52u w=8u l=0.28u
X169 VDD.t13 a_14220_41600.t47 O_SENSE.t0 VDD.t12 pfet_03v3 ad=2.08p pd=8.52u as=3.52p ps=16.88u w=8u l=0.28u
X170 a_14220_41600.t14 a_6924_41600.t14 VDD.t161 VDD.t160 pfet_03v3 ad=2.08p pd=8.52u as=2.08p ps=8.52u w=8u l=0.28u
X171 O_SENSE.t27 a_14220_41600.t30 VSS.t187 VSS.t186 nfet_03v3 ad=2.08p pd=8.52u as=2.08p ps=8.52u w=8u l=0.28u
X172 VDD.t5 a_14220_6400.t33 E_SENSE.t2 VDD.t4 pfet_03v3 ad=2.08p pd=8.52u as=2.08p ps=8.52u w=8u l=0.28u
X173 O_SENSE.t8 a_14220_41600.t44 VDD.t59 VDD.t58 pfet_03v3 ad=2.08p pd=8.52u as=2.08p ps=8.52u w=8u l=0.28u
X174 E_CAPTURE_CLKB.t6 a_2700_6400.t16 VDD.t81 VDD.t80 pfet_03v3 ad=3.52p pd=16.88u as=2.08p ps=8.52u w=8u l=0.28u
X175 O_CAPTURE_CLK.t7 a_4812_41600.t20 VDD.t49 VDD.t48 pfet_03v3 ad=2.08p pd=8.52u as=2.08p ps=8.52u w=8u l=0.28u
X176 VSS.t129 a_14220_41600.t27 O_SENSE.t14 VSS.t128 nfet_03v3 ad=2.08p pd=8.52u as=2.08p ps=8.52u w=8u l=0.28u
X177 a_2700_6400.t1 CLKP_HB.t10 VDD.t179 VDD.t178 pfet_03v3 ad=2.08p pd=8.52u as=2.08p ps=8.52u w=8u l=0.28u
X178 VSS.t195 a_6924_6400.t7 a_14220_6400.t15 VSS.t194 nfet_03v3 ad=2.08p pd=8.52u as=2.08p ps=8.52u w=8u l=0.28u
X179 a_2700_6400.t3 CLKP_HB.t8 VDD.t173 VDD.t172 pfet_03v3 ad=3.52p pd=16.88u as=2.08p ps=8.52u w=8u l=0.28u
X180 VSS.t39 a_6924_6400.t5 a_14220_6400.t2 VSS.t38 nfet_03v3 ad=2.08p pd=8.52u as=2.08p ps=8.52u w=8u l=0.28u
X181 a_14220_6400.t13 a_6924_6400.t16 VDD.t151 VDD.t150 pfet_03v3 ad=2.08p pd=8.52u as=2.08p ps=8.52u w=8u l=0.28u
X182 a_4812_41600.t1 CLKN_H.t6 VDD.t193 VDD.t192 pfet_03v3 ad=2.08p pd=8.52u as=2.08p ps=8.52u w=8u l=0.28u
X183 VDD.t15 a_4812_41600.t17 O_CAPTURE_CLK.t0 VDD.t14 pfet_03v3 ad=2.08p pd=8.52u as=2.08p ps=8.52u w=8u l=0.28u
X184 VSS.t91 a_14220_6400.t29 E_SENSE.t24 VSS.t90 nfet_03v3 ad=2.08p pd=8.52u as=2.08p ps=8.52u w=8u l=0.28u
X185 a_4812_6400.t3 CLKP_H.t4 VDD.t119 VDD.t118 pfet_03v3 ad=3.52p pd=16.88u as=2.08p ps=8.52u w=8u l=0.28u
X186 VSS.t177 CLKN_H.t1 a_4812_41600.t6 VSS.t176 nfet_03v3 ad=2.08p pd=8.52u as=2.08p ps=8.52u w=8u l=0.28u
X187 VSS.t141 a_6924_41600.t11 a_14220_41600.t10 VSS.t140 nfet_03v3 ad=2.08p pd=8.52u as=3.52p ps=16.88u w=8u l=0.28u
X188 VDD.t91 CLKN_HB.t9 a_2700_41600.t2 VDD.t90 pfet_03v3 ad=2.08p pd=8.52u as=2.08p ps=8.52u w=8u l=0.28u
X189 a_6924_41600.t1 CLKN_HB.t6 VDD.t93 VDD.t92 pfet_03v3 ad=3.52p pd=16.88u as=2.08p ps=8.52u w=8u l=0.28u
X190 VDD.t183 CLKP_HB.t9 a_2700_6400.t2 VDD.t182 pfet_03v3 ad=2.08p pd=8.52u as=2.08p ps=8.52u w=8u l=0.28u
X191 a_14220_6400.t3 a_6924_6400.t6 VSS.t41 VSS.t40 nfet_03v3 ad=2.08p pd=8.52u as=2.08p ps=8.52u w=8u l=0.28u
X192 VDD.t77 a_6924_6400.t17 a_14220_6400.t9 VDD.t76 pfet_03v3 ad=2.08p pd=8.52u as=2.08p ps=8.52u w=8u l=0.28u
X193 VDD.t159 a_6924_41600.t17 a_14220_41600.t12 VDD.t158 pfet_03v3 ad=2.08p pd=8.52u as=2.08p ps=8.52u w=8u l=0.28u
X194 VDD.t113 CLKP_H.t7 a_4812_6400.t0 VDD.t112 pfet_03v3 ad=2.08p pd=8.52u as=3.52p ps=16.88u w=8u l=0.28u
X195 O_CAPTURE_CLKB.t8 a_2700_41600.t20 VDD.t99 VDD.t98 pfet_03v3 ad=2.08p pd=8.52u as=2.08p ps=8.52u w=8u l=0.28u
X196 E_SENSE.t25 a_14220_6400.t30 VSS.t93 VSS.t92 nfet_03v3 ad=2.08p pd=8.52u as=2.08p ps=8.52u w=8u l=0.28u
X197 VDD.t115 CLKP_H.t5 a_4812_6400.t2 VDD.t114 pfet_03v3 ad=2.08p pd=8.52u as=2.08p ps=8.52u w=8u l=0.28u
X198 VDD.t35 a_4812_41600.t23 O_CAPTURE_CLK.t5 VDD.t34 pfet_03v3 ad=2.08p pd=8.52u as=3.52p ps=16.88u w=8u l=0.28u
X199 VDD.t19 a_14220_6400.t47 E_SENSE.t6 VDD.t18 pfet_03v3 ad=2.08p pd=8.52u as=3.52p ps=16.88u w=8u l=0.28u
R0 E_SENSE E_SENSE.n30 9.23374
R1 E_SENSE.n30 E_SENSE.n14 6.5392
R2 E_SENSE.n16 E_SENSE.t13 5.7796
R3 E_SENSE.n1 E_SENSE.t10 5.73764
R4 E_SENSE.n29 E_SENSE.t9 5.59012
R5 E_SENSE.n14 E_SENSE.t6 5.54817
R6 E_SENSE.n16 E_SENSE.n15 5.38537
R7 E_SENSE.n18 E_SENSE.n17 5.38537
R8 E_SENSE.n20 E_SENSE.n19 5.38537
R9 E_SENSE.n22 E_SENSE.n21 5.38537
R10 E_SENSE.n24 E_SENSE.n23 5.38537
R11 E_SENSE.n26 E_SENSE.n25 5.38537
R12 E_SENSE.n28 E_SENSE.n27 5.38537
R13 E_SENSE.n1 E_SENSE.n0 5.32067
R14 E_SENSE.n3 E_SENSE.n2 5.32067
R15 E_SENSE.n5 E_SENSE.n4 5.32067
R16 E_SENSE.n7 E_SENSE.n6 5.32067
R17 E_SENSE.n9 E_SENSE.n8 5.32067
R18 E_SENSE.n11 E_SENSE.n10 5.32067
R19 E_SENSE.n13 E_SENSE.n12 5.32067
R20 E_SENSE.n30 E_SENSE.n29 4.61063
R21 E_SENSE.n0 E_SENSE.t3 0.228
R22 E_SENSE.n0 E_SENSE.t2 0.228
R23 E_SENSE.n2 E_SENSE.t17 0.228
R24 E_SENSE.n2 E_SENSE.t16 0.228
R25 E_SENSE.n4 E_SENSE.t23 0.228
R26 E_SENSE.n4 E_SENSE.t22 0.228
R27 E_SENSE.n6 E_SENSE.t8 0.228
R28 E_SENSE.n6 E_SENSE.t7 0.228
R29 E_SENSE.n8 E_SENSE.t1 0.228
R30 E_SENSE.n8 E_SENSE.t0 0.228
R31 E_SENSE.n10 E_SENSE.t15 0.228
R32 E_SENSE.n10 E_SENSE.t14 0.228
R33 E_SENSE.n12 E_SENSE.t21 0.228
R34 E_SENSE.n12 E_SENSE.t20 0.228
R35 E_SENSE.n15 E_SENSE.t31 0.20525
R36 E_SENSE.n15 E_SENSE.t30 0.20525
R37 E_SENSE.n17 E_SENSE.t27 0.20525
R38 E_SENSE.n17 E_SENSE.t26 0.20525
R39 E_SENSE.n19 E_SENSE.t12 0.20525
R40 E_SENSE.n19 E_SENSE.t11 0.20525
R41 E_SENSE.n21 E_SENSE.t5 0.20525
R42 E_SENSE.n21 E_SENSE.t4 0.20525
R43 E_SENSE.n23 E_SENSE.t19 0.20525
R44 E_SENSE.n23 E_SENSE.t18 0.20525
R45 E_SENSE.n25 E_SENSE.t29 0.20525
R46 E_SENSE.n25 E_SENSE.t28 0.20525
R47 E_SENSE.n27 E_SENSE.t25 0.20525
R48 E_SENSE.n27 E_SENSE.t24 0.20525
R49 E_SENSE.n29 E_SENSE.n28 0.189974
R50 E_SENSE.n28 E_SENSE.n26 0.189974
R51 E_SENSE.n26 E_SENSE.n24 0.189974
R52 E_SENSE.n24 E_SENSE.n22 0.189974
R53 E_SENSE.n22 E_SENSE.n20 0.189974
R54 E_SENSE.n20 E_SENSE.n18 0.189974
R55 E_SENSE.n18 E_SENSE.n16 0.189974
R56 E_SENSE.n14 E_SENSE.n13 0.189974
R57 E_SENSE.n13 E_SENSE.n11 0.189974
R58 E_SENSE.n11 E_SENSE.n9 0.189974
R59 E_SENSE.n9 E_SENSE.n7 0.189974
R60 E_SENSE.n7 E_SENSE.n5 0.189974
R61 E_SENSE.n5 E_SENSE.n3 0.189974
R62 E_SENSE.n3 E_SENSE.n1 0.189974
R63 E_CAPTURE_CLK E_CAPTURE_CLK.n14 7.98157
R64 E_CAPTURE_CLK.n14 E_CAPTURE_CLK.n6 6.5392
R65 E_CAPTURE_CLK.n8 E_CAPTURE_CLK.t2 5.7796
R66 E_CAPTURE_CLK.n1 E_CAPTURE_CLK.t0 5.73764
R67 E_CAPTURE_CLK.n13 E_CAPTURE_CLK.t9 5.59012
R68 E_CAPTURE_CLK.n6 E_CAPTURE_CLK.t13 5.54817
R69 E_CAPTURE_CLK.n8 E_CAPTURE_CLK.n7 5.38537
R70 E_CAPTURE_CLK.n10 E_CAPTURE_CLK.n9 5.38537
R71 E_CAPTURE_CLK.n12 E_CAPTURE_CLK.n11 5.38537
R72 E_CAPTURE_CLK.n1 E_CAPTURE_CLK.n0 5.32067
R73 E_CAPTURE_CLK.n3 E_CAPTURE_CLK.n2 5.32067
R74 E_CAPTURE_CLK.n5 E_CAPTURE_CLK.n4 5.32067
R75 E_CAPTURE_CLK.n14 E_CAPTURE_CLK.n13 4.61063
R76 E_CAPTURE_CLK.n0 E_CAPTURE_CLK.t14 0.228
R77 E_CAPTURE_CLK.n0 E_CAPTURE_CLK.t1 0.228
R78 E_CAPTURE_CLK.n2 E_CAPTURE_CLK.t10 0.228
R79 E_CAPTURE_CLK.n2 E_CAPTURE_CLK.t15 0.228
R80 E_CAPTURE_CLK.n4 E_CAPTURE_CLK.t12 0.228
R81 E_CAPTURE_CLK.n4 E_CAPTURE_CLK.t11 0.228
R82 E_CAPTURE_CLK.n7 E_CAPTURE_CLK.t4 0.20525
R83 E_CAPTURE_CLK.n7 E_CAPTURE_CLK.t3 0.20525
R84 E_CAPTURE_CLK.n9 E_CAPTURE_CLK.t6 0.20525
R85 E_CAPTURE_CLK.n9 E_CAPTURE_CLK.t5 0.20525
R86 E_CAPTURE_CLK.n11 E_CAPTURE_CLK.t8 0.20525
R87 E_CAPTURE_CLK.n11 E_CAPTURE_CLK.t7 0.20525
R88 E_CAPTURE_CLK.n13 E_CAPTURE_CLK.n12 0.189974
R89 E_CAPTURE_CLK.n12 E_CAPTURE_CLK.n10 0.189974
R90 E_CAPTURE_CLK.n10 E_CAPTURE_CLK.n8 0.189974
R91 E_CAPTURE_CLK.n6 E_CAPTURE_CLK.n5 0.189974
R92 E_CAPTURE_CLK.n5 E_CAPTURE_CLK.n3 0.189974
R93 E_CAPTURE_CLK.n3 E_CAPTURE_CLK.n1 0.189974
R94 E_CAPTURE_CLKB E_CAPTURE_CLKB.n14 6.63157
R95 E_CAPTURE_CLKB.n14 E_CAPTURE_CLKB.n6 6.5392
R96 E_CAPTURE_CLKB.n8 E_CAPTURE_CLKB.t2 5.7796
R97 E_CAPTURE_CLKB.n1 E_CAPTURE_CLKB.t6 5.73764
R98 E_CAPTURE_CLKB.n13 E_CAPTURE_CLKB.t5 5.59012
R99 E_CAPTURE_CLKB.n6 E_CAPTURE_CLKB.t7 5.54817
R100 E_CAPTURE_CLKB.n8 E_CAPTURE_CLKB.n7 5.38537
R101 E_CAPTURE_CLKB.n10 E_CAPTURE_CLKB.n9 5.38537
R102 E_CAPTURE_CLKB.n12 E_CAPTURE_CLKB.n11 5.38537
R103 E_CAPTURE_CLKB.n1 E_CAPTURE_CLKB.n0 5.32067
R104 E_CAPTURE_CLKB.n3 E_CAPTURE_CLKB.n2 5.32067
R105 E_CAPTURE_CLKB.n5 E_CAPTURE_CLKB.n4 5.32067
R106 E_CAPTURE_CLKB.n14 E_CAPTURE_CLKB.n13 4.61063
R107 E_CAPTURE_CLKB.n0 E_CAPTURE_CLKB.t4 0.228
R108 E_CAPTURE_CLKB.n0 E_CAPTURE_CLKB.t3 0.228
R109 E_CAPTURE_CLKB.n2 E_CAPTURE_CLKB.t1 0.228
R110 E_CAPTURE_CLKB.n2 E_CAPTURE_CLKB.t0 0.228
R111 E_CAPTURE_CLKB.n4 E_CAPTURE_CLKB.t11 0.228
R112 E_CAPTURE_CLKB.n4 E_CAPTURE_CLKB.t10 0.228
R113 E_CAPTURE_CLKB.n7 E_CAPTURE_CLKB.t9 0.20525
R114 E_CAPTURE_CLKB.n7 E_CAPTURE_CLKB.t8 0.20525
R115 E_CAPTURE_CLKB.n9 E_CAPTURE_CLKB.t13 0.20525
R116 E_CAPTURE_CLKB.n9 E_CAPTURE_CLKB.t12 0.20525
R117 E_CAPTURE_CLKB.n11 E_CAPTURE_CLKB.t15 0.20525
R118 E_CAPTURE_CLKB.n11 E_CAPTURE_CLKB.t14 0.20525
R119 E_CAPTURE_CLKB.n13 E_CAPTURE_CLKB.n12 0.189974
R120 E_CAPTURE_CLKB.n12 E_CAPTURE_CLKB.n10 0.189974
R121 E_CAPTURE_CLKB.n10 E_CAPTURE_CLKB.n8 0.189974
R122 E_CAPTURE_CLKB.n6 E_CAPTURE_CLKB.n5 0.189974
R123 E_CAPTURE_CLKB.n5 E_CAPTURE_CLKB.n3 0.189974
R124 E_CAPTURE_CLKB.n3 E_CAPTURE_CLKB.n1 0.189974
R125 CLKP_H.n8 CLKP_H.t3 113.632
R126 CLKP_H.n5 CLKP_H.t0 113.632
R127 CLKP_H.n0 CLKP_H.t4 113.632
R128 CLKP_H.n3 CLKP_H.t7 113.632
R129 CLKP_H.n6 CLKP_H.t1 109.174
R130 CLKP_H.n7 CLKP_H.t2 109.174
R131 CLKP_H.n1 CLKP_H.t5 109.174
R132 CLKP_H.n2 CLKP_H.t6 109.174
R133 CLKP_H CLKP_H.n10 15.3874
R134 CLKP_H.n7 CLKP_H.n6 11.6805
R135 CLKP_H.n2 CLKP_H.n1 11.6805
R136 CLKP_H.n10 CLKP_H.n4 10.9291
R137 CLKP_H.n10 CLKP_H.n9 9.0005
R138 CLKP_H.n9 CLKP_H.n5 7.10487
R139 CLKP_H.n9 CLKP_H.n8 7.10487
R140 CLKP_H.n4 CLKP_H.n0 7.10487
R141 CLKP_H.n4 CLKP_H.n3 7.10487
R142 CLKP_H.n6 CLKP_H.n5 4.42851
R143 CLKP_H.n8 CLKP_H.n7 4.42851
R144 CLKP_H.n1 CLKP_H.n0 4.42851
R145 CLKP_H.n3 CLKP_H.n2 4.42851
R146 CLKP_HB.n11 CLKP_HB.t5 113.632
R147 CLKP_HB.n8 CLKP_HB.t2 113.632
R148 CLKP_HB.n3 CLKP_HB.t8 113.632
R149 CLKP_HB.n6 CLKP_HB.t11 113.632
R150 CLKP_HB.n1 CLKP_HB.t0 113.618
R151 CLKP_HB.n1 CLKP_HB.t1 113.618
R152 CLKP_HB.n0 CLKP_HB.t6 113.618
R153 CLKP_HB.n0 CLKP_HB.t7 113.618
R154 CLKP_HB.n9 CLKP_HB.t3 109.174
R155 CLKP_HB.n10 CLKP_HB.t4 109.174
R156 CLKP_HB.n4 CLKP_HB.t9 109.174
R157 CLKP_HB.n5 CLKP_HB.t10 109.174
R158 CLKP_HB.n2 CLKP_HB.n0 17.9899
R159 CLKP_HB.n2 CLKP_HB.n1 16.0613
R160 CLKP_HB.n10 CLKP_HB.n9 11.6805
R161 CLKP_HB.n5 CLKP_HB.n4 11.6805
R162 CLKP_HB.n13 CLKP_HB.n7 10.9291
R163 CLKP_HB.n13 CLKP_HB.n12 9.0005
R164 CLKP_HB.n14 CLKP_HB.n2 8.55302
R165 CLKP_HB CLKP_HB.n14 8.25354
R166 CLKP_HB.n12 CLKP_HB.n8 7.10487
R167 CLKP_HB.n12 CLKP_HB.n11 7.10487
R168 CLKP_HB.n7 CLKP_HB.n3 7.10487
R169 CLKP_HB.n7 CLKP_HB.n6 7.10487
R170 CLKP_HB.n14 CLKP_HB.n13 4.59693
R171 CLKP_HB.n9 CLKP_HB.n8 4.42851
R172 CLKP_HB.n11 CLKP_HB.n10 4.42851
R173 CLKP_HB.n4 CLKP_HB.n3 4.42851
R174 CLKP_HB.n6 CLKP_HB.n5 4.42851
R175 O_SENSE O_SENSE.n30 9.23374
R176 O_SENSE.n30 O_SENSE.n14 6.5392
R177 O_SENSE.n16 O_SENSE.t9 5.7796
R178 O_SENSE.n1 O_SENSE.t13 5.73764
R179 O_SENSE.n29 O_SENSE.t12 5.59012
R180 O_SENSE.n14 O_SENSE.t0 5.54817
R181 O_SENSE.n16 O_SENSE.n15 5.38537
R182 O_SENSE.n18 O_SENSE.n17 5.38537
R183 O_SENSE.n20 O_SENSE.n19 5.38537
R184 O_SENSE.n22 O_SENSE.n21 5.38537
R185 O_SENSE.n24 O_SENSE.n23 5.38537
R186 O_SENSE.n26 O_SENSE.n25 5.38537
R187 O_SENSE.n28 O_SENSE.n27 5.38537
R188 O_SENSE.n1 O_SENSE.n0 5.32067
R189 O_SENSE.n3 O_SENSE.n2 5.32067
R190 O_SENSE.n5 O_SENSE.n4 5.32067
R191 O_SENSE.n7 O_SENSE.n6 5.32067
R192 O_SENSE.n9 O_SENSE.n8 5.32067
R193 O_SENSE.n11 O_SENSE.n10 5.32067
R194 O_SENSE.n13 O_SENSE.n12 5.32067
R195 O_SENSE.n30 O_SENSE.n29 4.61063
R196 O_SENSE.n0 O_SENSE.t21 0.228
R197 O_SENSE.n0 O_SENSE.t20 0.228
R198 O_SENSE.n2 O_SENSE.t11 0.228
R199 O_SENSE.n2 O_SENSE.t10 0.228
R200 O_SENSE.n4 O_SENSE.t4 0.228
R201 O_SENSE.n4 O_SENSE.t3 0.228
R202 O_SENSE.n6 O_SENSE.t6 0.228
R203 O_SENSE.n6 O_SENSE.t5 0.228
R204 O_SENSE.n8 O_SENSE.t29 0.228
R205 O_SENSE.n8 O_SENSE.t28 0.228
R206 O_SENSE.n10 O_SENSE.t8 0.228
R207 O_SENSE.n10 O_SENSE.t7 0.228
R208 O_SENSE.n12 O_SENSE.t17 0.228
R209 O_SENSE.n12 O_SENSE.t16 0.228
R210 O_SENSE.n15 O_SENSE.t2 0.20525
R211 O_SENSE.n15 O_SENSE.t1 0.20525
R212 O_SENSE.n17 O_SENSE.t25 0.20525
R213 O_SENSE.n17 O_SENSE.t24 0.20525
R214 O_SENSE.n19 O_SENSE.t23 0.20525
R215 O_SENSE.n19 O_SENSE.t22 0.20525
R216 O_SENSE.n21 O_SENSE.t31 0.20525
R217 O_SENSE.n21 O_SENSE.t30 0.20525
R218 O_SENSE.n23 O_SENSE.t19 0.20525
R219 O_SENSE.n23 O_SENSE.t18 0.20525
R220 O_SENSE.n25 O_SENSE.t15 0.20525
R221 O_SENSE.n25 O_SENSE.t14 0.20525
R222 O_SENSE.n27 O_SENSE.t27 0.20525
R223 O_SENSE.n27 O_SENSE.t26 0.20525
R224 O_SENSE.n29 O_SENSE.n28 0.189974
R225 O_SENSE.n28 O_SENSE.n26 0.189974
R226 O_SENSE.n26 O_SENSE.n24 0.189974
R227 O_SENSE.n24 O_SENSE.n22 0.189974
R228 O_SENSE.n22 O_SENSE.n20 0.189974
R229 O_SENSE.n20 O_SENSE.n18 0.189974
R230 O_SENSE.n18 O_SENSE.n16 0.189974
R231 O_SENSE.n14 O_SENSE.n13 0.189974
R232 O_SENSE.n13 O_SENSE.n11 0.189974
R233 O_SENSE.n11 O_SENSE.n9 0.189974
R234 O_SENSE.n9 O_SENSE.n7 0.189974
R235 O_SENSE.n7 O_SENSE.n5 0.189974
R236 O_SENSE.n5 O_SENSE.n3 0.189974
R237 O_SENSE.n3 O_SENSE.n1 0.189974
R238 O_CAPTURE_CLK O_CAPTURE_CLK.n14 7.98157
R239 O_CAPTURE_CLK.n14 O_CAPTURE_CLK.n6 6.5392
R240 O_CAPTURE_CLK.n8 O_CAPTURE_CLK.t4 5.7796
R241 O_CAPTURE_CLK.n1 O_CAPTURE_CLK.t15 5.73764
R242 O_CAPTURE_CLK.n13 O_CAPTURE_CLK.t14 5.59012
R243 O_CAPTURE_CLK.n6 O_CAPTURE_CLK.t5 5.54817
R244 O_CAPTURE_CLK.n8 O_CAPTURE_CLK.n7 5.38537
R245 O_CAPTURE_CLK.n10 O_CAPTURE_CLK.n9 5.38537
R246 O_CAPTURE_CLK.n12 O_CAPTURE_CLK.n11 5.38537
R247 O_CAPTURE_CLK.n1 O_CAPTURE_CLK.n0 5.32067
R248 O_CAPTURE_CLK.n3 O_CAPTURE_CLK.n2 5.32067
R249 O_CAPTURE_CLK.n5 O_CAPTURE_CLK.n4 5.32067
R250 O_CAPTURE_CLK.n14 O_CAPTURE_CLK.n13 4.61063
R251 O_CAPTURE_CLK.n0 O_CAPTURE_CLK.t1 0.228
R252 O_CAPTURE_CLK.n0 O_CAPTURE_CLK.t0 0.228
R253 O_CAPTURE_CLK.n2 O_CAPTURE_CLK.t7 0.228
R254 O_CAPTURE_CLK.n2 O_CAPTURE_CLK.t6 0.228
R255 O_CAPTURE_CLK.n4 O_CAPTURE_CLK.t13 0.228
R256 O_CAPTURE_CLK.n4 O_CAPTURE_CLK.t12 0.228
R257 O_CAPTURE_CLK.n7 O_CAPTURE_CLK.t11 0.20525
R258 O_CAPTURE_CLK.n7 O_CAPTURE_CLK.t10 0.20525
R259 O_CAPTURE_CLK.n9 O_CAPTURE_CLK.t3 0.20525
R260 O_CAPTURE_CLK.n9 O_CAPTURE_CLK.t2 0.20525
R261 O_CAPTURE_CLK.n11 O_CAPTURE_CLK.t9 0.20525
R262 O_CAPTURE_CLK.n11 O_CAPTURE_CLK.t8 0.20525
R263 O_CAPTURE_CLK.n13 O_CAPTURE_CLK.n12 0.189974
R264 O_CAPTURE_CLK.n12 O_CAPTURE_CLK.n10 0.189974
R265 O_CAPTURE_CLK.n10 O_CAPTURE_CLK.n8 0.189974
R266 O_CAPTURE_CLK.n6 O_CAPTURE_CLK.n5 0.189974
R267 O_CAPTURE_CLK.n5 O_CAPTURE_CLK.n3 0.189974
R268 O_CAPTURE_CLK.n3 O_CAPTURE_CLK.n1 0.189974
R269 O_CAPTURE_CLKB O_CAPTURE_CLKB.n14 6.63157
R270 O_CAPTURE_CLKB.n14 O_CAPTURE_CLKB.n6 6.5392
R271 O_CAPTURE_CLKB.n8 O_CAPTURE_CLKB.t15 5.7796
R272 O_CAPTURE_CLKB.n1 O_CAPTURE_CLKB.t10 5.73764
R273 O_CAPTURE_CLKB.n13 O_CAPTURE_CLKB.t1 5.59012
R274 O_CAPTURE_CLKB.n6 O_CAPTURE_CLKB.t7 5.54817
R275 O_CAPTURE_CLKB.n8 O_CAPTURE_CLKB.n7 5.38537
R276 O_CAPTURE_CLKB.n10 O_CAPTURE_CLKB.n9 5.38537
R277 O_CAPTURE_CLKB.n12 O_CAPTURE_CLKB.n11 5.38537
R278 O_CAPTURE_CLKB.n1 O_CAPTURE_CLKB.n0 5.32067
R279 O_CAPTURE_CLKB.n3 O_CAPTURE_CLKB.n2 5.32067
R280 O_CAPTURE_CLKB.n5 O_CAPTURE_CLKB.n4 5.32067
R281 O_CAPTURE_CLKB.n14 O_CAPTURE_CLKB.n13 4.61063
R282 O_CAPTURE_CLKB.n0 O_CAPTURE_CLKB.t12 0.228
R283 O_CAPTURE_CLKB.n0 O_CAPTURE_CLKB.t11 0.228
R284 O_CAPTURE_CLKB.n2 O_CAPTURE_CLKB.t8 0.228
R285 O_CAPTURE_CLKB.n2 O_CAPTURE_CLKB.t13 0.228
R286 O_CAPTURE_CLKB.n4 O_CAPTURE_CLKB.t6 0.228
R287 O_CAPTURE_CLKB.n4 O_CAPTURE_CLKB.t9 0.228
R288 O_CAPTURE_CLKB.n7 O_CAPTURE_CLKB.t2 0.20525
R289 O_CAPTURE_CLKB.n7 O_CAPTURE_CLKB.t14 0.20525
R290 O_CAPTURE_CLKB.n9 O_CAPTURE_CLKB.t4 0.20525
R291 O_CAPTURE_CLKB.n9 O_CAPTURE_CLKB.t3 0.20525
R292 O_CAPTURE_CLKB.n11 O_CAPTURE_CLKB.t0 0.20525
R293 O_CAPTURE_CLKB.n11 O_CAPTURE_CLKB.t5 0.20525
R294 O_CAPTURE_CLKB.n13 O_CAPTURE_CLKB.n12 0.189974
R295 O_CAPTURE_CLKB.n12 O_CAPTURE_CLKB.n10 0.189974
R296 O_CAPTURE_CLKB.n10 O_CAPTURE_CLKB.n8 0.189974
R297 O_CAPTURE_CLKB.n6 O_CAPTURE_CLKB.n5 0.189974
R298 O_CAPTURE_CLKB.n5 O_CAPTURE_CLKB.n3 0.189974
R299 O_CAPTURE_CLKB.n3 O_CAPTURE_CLKB.n1 0.189974
R300 CLKN_H.n8 CLKN_H.t3 113.632
R301 CLKN_H.n5 CLKN_H.t0 113.632
R302 CLKN_H.n0 CLKN_H.t4 113.632
R303 CLKN_H.n3 CLKN_H.t7 113.632
R304 CLKN_H.n6 CLKN_H.t1 109.174
R305 CLKN_H.n7 CLKN_H.t2 109.174
R306 CLKN_H.n1 CLKN_H.t5 109.174
R307 CLKN_H.n2 CLKN_H.t6 109.174
R308 CLKN_H CLKN_H.n10 15.3874
R309 CLKN_H.n7 CLKN_H.n6 11.6805
R310 CLKN_H.n2 CLKN_H.n1 11.6805
R311 CLKN_H.n10 CLKN_H.n4 10.9291
R312 CLKN_H.n10 CLKN_H.n9 9.0005
R313 CLKN_H.n9 CLKN_H.n5 7.10487
R314 CLKN_H.n9 CLKN_H.n8 7.10487
R315 CLKN_H.n4 CLKN_H.n0 7.10487
R316 CLKN_H.n4 CLKN_H.n3 7.10487
R317 CLKN_H.n6 CLKN_H.n5 4.42851
R318 CLKN_H.n8 CLKN_H.n7 4.42851
R319 CLKN_H.n1 CLKN_H.n0 4.42851
R320 CLKN_H.n3 CLKN_H.n2 4.42851
R321 CLKN_HB.n11 CLKN_HB.t5 113.632
R322 CLKN_HB.n8 CLKN_HB.t2 113.632
R323 CLKN_HB.n3 CLKN_HB.t8 113.632
R324 CLKN_HB.n6 CLKN_HB.t11 113.632
R325 CLKN_HB.n1 CLKN_HB.t0 113.618
R326 CLKN_HB.n1 CLKN_HB.t1 113.618
R327 CLKN_HB.n0 CLKN_HB.t6 113.618
R328 CLKN_HB.n0 CLKN_HB.t7 113.618
R329 CLKN_HB.n9 CLKN_HB.t3 109.174
R330 CLKN_HB.n10 CLKN_HB.t4 109.174
R331 CLKN_HB.n4 CLKN_HB.t9 109.174
R332 CLKN_HB.n5 CLKN_HB.t10 109.174
R333 CLKN_HB.n2 CLKN_HB.n0 17.9899
R334 CLKN_HB.n2 CLKN_HB.n1 16.0613
R335 CLKN_HB.n10 CLKN_HB.n9 11.6805
R336 CLKN_HB.n5 CLKN_HB.n4 11.6805
R337 CLKN_HB.n13 CLKN_HB.n7 10.9291
R338 CLKN_HB CLKN_HB.n14 9.03615
R339 CLKN_HB.n13 CLKN_HB.n12 9.0005
R340 CLKN_HB.n14 CLKN_HB.n2 8.55302
R341 CLKN_HB.n12 CLKN_HB.n8 7.10487
R342 CLKN_HB.n12 CLKN_HB.n11 7.10487
R343 CLKN_HB.n7 CLKN_HB.n3 7.10487
R344 CLKN_HB.n7 CLKN_HB.n6 7.10487
R345 CLKN_HB.n14 CLKN_HB.n13 4.59693
R346 CLKN_HB.n9 CLKN_HB.n8 4.42851
R347 CLKN_HB.n11 CLKN_HB.n10 4.42851
R348 CLKN_HB.n4 CLKN_HB.n3 4.42851
R349 CLKN_HB.n6 CLKN_HB.n5 4.42851
R350 VDD.t82 VDD.t190 450.829
R351 VDD.t194 VDD.t84 450.829
R352 VDD.t92 VDD.t96 450.829
R353 VDD.t164 VDD.t34 450.829
R354 VDD.t126 VDD.t144 450.829
R355 VDD.t146 VDD.t12 450.829
R356 VDD.t172 VDD.t112 450.829
R357 VDD.t118 VDD.t180 450.829
R358 VDD.t174 VDD.t132 450.829
R359 VDD.t80 VDD.t140 450.829
R360 VDD.t8 VDD.t102 450.829
R361 VDD.t50 VDD.t18 450.829
R362 VDD.n101 VDD.t86 417.582
R363 VDD.n50 VDD.t176 417.582
R364 VDD.t86 VDD.t88 44.1994
R365 VDD.t88 VDD.t90 44.1994
R366 VDD.t90 VDD.t82 44.1994
R367 VDD.t190 VDD.t192 44.1994
R368 VDD.t192 VDD.t188 44.1994
R369 VDD.t188 VDD.t194 44.1994
R370 VDD.t84 VDD.t92 44.1994
R371 VDD.t96 VDD.t94 44.1994
R372 VDD.t94 VDD.t100 44.1994
R373 VDD.t100 VDD.t98 44.1994
R374 VDD.t98 VDD.t170 44.1994
R375 VDD.t170 VDD.t168 44.1994
R376 VDD.t168 VDD.t166 44.1994
R377 VDD.t166 VDD.t164 44.1994
R378 VDD.t34 VDD.t110 44.1994
R379 VDD.t110 VDD.t108 44.1994
R380 VDD.t108 VDD.t48 44.1994
R381 VDD.t48 VDD.t46 44.1994
R382 VDD.t46 VDD.t16 44.1994
R383 VDD.t16 VDD.t14 44.1994
R384 VDD.t14 VDD.t126 44.1994
R385 VDD.t144 VDD.t142 44.1994
R386 VDD.t142 VDD.t158 44.1994
R387 VDD.t158 VDD.t156 44.1994
R388 VDD.t156 VDD.t162 44.1994
R389 VDD.t162 VDD.t160 44.1994
R390 VDD.t160 VDD.t44 44.1994
R391 VDD.t44 VDD.t146 44.1994
R392 VDD.t12 VDD.t130 44.1994
R393 VDD.t130 VDD.t128 44.1994
R394 VDD.t128 VDD.t58 44.1994
R395 VDD.t58 VDD.t56 44.1994
R396 VDD.t56 VDD.t198 44.1994
R397 VDD.t198 VDD.t196 44.1994
R398 VDD.t196 VDD.t54 44.1994
R399 VDD.t54 VDD.t52 44.1994
R400 VDD.t52 VDD.t32 44.1994
R401 VDD.t32 VDD.t30 44.1994
R402 VDD.t30 VDD.t106 44.1994
R403 VDD.t106 VDD.t104 44.1994
R404 VDD.t104 VDD.t136 44.1994
R405 VDD.t136 VDD.t134 44.1994
R406 VDD.t134 VDD.t124 44.1994
R407 VDD.t176 VDD.t178 44.1994
R408 VDD.t178 VDD.t182 44.1994
R409 VDD.t182 VDD.t172 44.1994
R410 VDD.t112 VDD.t116 44.1994
R411 VDD.t116 VDD.t114 44.1994
R412 VDD.t114 VDD.t118 44.1994
R413 VDD.t180 VDD.t174 44.1994
R414 VDD.t132 VDD.t186 44.1994
R415 VDD.t186 VDD.t184 44.1994
R416 VDD.t184 VDD.t28 44.1994
R417 VDD.t28 VDD.t26 44.1994
R418 VDD.t26 VDD.t70 44.1994
R419 VDD.t70 VDD.t68 44.1994
R420 VDD.t68 VDD.t80 44.1994
R421 VDD.t140 VDD.t138 44.1994
R422 VDD.t138 VDD.t122 44.1994
R423 VDD.t122 VDD.t120 44.1994
R424 VDD.t120 VDD.t154 44.1994
R425 VDD.t154 VDD.t152 44.1994
R426 VDD.t152 VDD.t10 44.1994
R427 VDD.t10 VDD.t8 44.1994
R428 VDD.t102 VDD.t78 44.1994
R429 VDD.t78 VDD.t76 44.1994
R430 VDD.t76 VDD.t150 44.1994
R431 VDD.t150 VDD.t148 44.1994
R432 VDD.t148 VDD.t74 44.1994
R433 VDD.t74 VDD.t72 44.1994
R434 VDD.t72 VDD.t50 44.1994
R435 VDD.t18 VDD.t62 44.1994
R436 VDD.t62 VDD.t60 44.1994
R437 VDD.t60 VDD.t38 44.1994
R438 VDD.t38 VDD.t36 44.1994
R439 VDD.t36 VDD.t2 44.1994
R440 VDD.t2 VDD.t0 44.1994
R441 VDD.t0 VDD.t22 44.1994
R442 VDD.t22 VDD.t20 44.1994
R443 VDD.t20 VDD.t66 44.1994
R444 VDD.t66 VDD.t64 44.1994
R445 VDD.t64 VDD.t42 44.1994
R446 VDD.t42 VDD.t40 44.1994
R447 VDD.t40 VDD.t6 44.1994
R448 VDD.t6 VDD.t4 44.1994
R449 VDD.t4 VDD.t24 44.1994
R450 VDD.n92 VDD.n91 16.4863
R451 VDD.n41 VDD.n40 16.4863
R452 VDD.n74 VDD.n66 11.6197
R453 VDD.n23 VDD.n15 11.6197
R454 VDD.n74 VDD.n73 11.1661
R455 VDD.n82 VDD.n81 11.1661
R456 VDD.n90 VDD.n89 11.1661
R457 VDD.n96 VDD.n95 11.1661
R458 VDD.n100 VDD.n99 11.1661
R459 VDD.n23 VDD.n22 11.1661
R460 VDD.n31 VDD.n30 11.1661
R461 VDD.n39 VDD.n38 11.1661
R462 VDD.n45 VDD.n44 11.1661
R463 VDD.n49 VDD.n48 11.1661
R464 VDD.n54 VDD.n52 5.51014
R465 VDD.n69 VDD.n67 5.51014
R466 VDD.n77 VDD.n75 5.51014
R467 VDD.n85 VDD.n83 5.51014
R468 VDD.n95 VDD.n93 5.51014
R469 VDD.n99 VDD.n97 5.51014
R470 VDD.n3 VDD.n1 5.51014
R471 VDD.n18 VDD.n16 5.51014
R472 VDD.n26 VDD.n24 5.51014
R473 VDD.n34 VDD.n32 5.51014
R474 VDD.n44 VDD.n42 5.51014
R475 VDD.n48 VDD.n46 5.51014
R476 VDD.n66 VDD.n65 5.32067
R477 VDD.n64 VDD.n63 5.32067
R478 VDD.n62 VDD.n61 5.32067
R479 VDD.n60 VDD.n59 5.32067
R480 VDD.n58 VDD.n57 5.32067
R481 VDD.n56 VDD.n55 5.32067
R482 VDD.n54 VDD.n53 5.32067
R483 VDD.n73 VDD.n72 5.32067
R484 VDD.n71 VDD.n70 5.32067
R485 VDD.n69 VDD.n68 5.32067
R486 VDD.n81 VDD.n80 5.32067
R487 VDD.n79 VDD.n78 5.32067
R488 VDD.n77 VDD.n76 5.32067
R489 VDD.n89 VDD.n88 5.32067
R490 VDD.n87 VDD.n86 5.32067
R491 VDD.n85 VDD.n84 5.32067
R492 VDD.n95 VDD.n94 5.32067
R493 VDD.n99 VDD.n98 5.32067
R494 VDD.n15 VDD.n14 5.32067
R495 VDD.n13 VDD.n12 5.32067
R496 VDD.n11 VDD.n10 5.32067
R497 VDD.n9 VDD.n8 5.32067
R498 VDD.n7 VDD.n6 5.32067
R499 VDD.n5 VDD.n4 5.32067
R500 VDD.n3 VDD.n2 5.32067
R501 VDD.n22 VDD.n21 5.32067
R502 VDD.n20 VDD.n19 5.32067
R503 VDD.n18 VDD.n17 5.32067
R504 VDD.n30 VDD.n29 5.32067
R505 VDD.n28 VDD.n27 5.32067
R506 VDD.n26 VDD.n25 5.32067
R507 VDD.n38 VDD.n37 5.32067
R508 VDD.n36 VDD.n35 5.32067
R509 VDD.n34 VDD.n33 5.32067
R510 VDD.n44 VDD.n43 5.32067
R511 VDD.n48 VDD.n47 5.32067
R512 VDD.n51 VDD.n0 4.5005
R513 VDD.n102 VDD.n0 4.5005
R514 VDD.n51 VDD.n50 3.31749
R515 VDD.n102 VDD.n101 2.77651
R516 VDD.n104 VDD.n103 2.26839
R517 VDD VDD.n104 1.13544
R518 VDD.n92 VDD.n90 0.3101
R519 VDD.n90 VDD.n82 0.3101
R520 VDD.n82 VDD.n74 0.3101
R521 VDD.n41 VDD.n39 0.3101
R522 VDD.n39 VDD.n31 0.3101
R523 VDD.n31 VDD.n23 0.3101
R524 VDD.n101 VDD.n100 0.244205
R525 VDD.n50 VDD.n49 0.244205
R526 VDD.n100 VDD.n96 0.2381
R527 VDD.n49 VDD.n45 0.2381
R528 VDD.n65 VDD.t135 0.228
R529 VDD.n65 VDD.t125 0.228
R530 VDD.n63 VDD.t105 0.228
R531 VDD.n63 VDD.t137 0.228
R532 VDD.n61 VDD.t31 0.228
R533 VDD.n61 VDD.t107 0.228
R534 VDD.n59 VDD.t53 0.228
R535 VDD.n59 VDD.t33 0.228
R536 VDD.n57 VDD.t197 0.228
R537 VDD.n57 VDD.t55 0.228
R538 VDD.n55 VDD.t57 0.228
R539 VDD.n55 VDD.t199 0.228
R540 VDD.n53 VDD.t129 0.228
R541 VDD.n53 VDD.t59 0.228
R542 VDD.n52 VDD.t13 0.228
R543 VDD.n52 VDD.t131 0.228
R544 VDD.n72 VDD.t45 0.228
R545 VDD.n72 VDD.t147 0.228
R546 VDD.n70 VDD.t163 0.228
R547 VDD.n70 VDD.t161 0.228
R548 VDD.n68 VDD.t159 0.228
R549 VDD.n68 VDD.t157 0.228
R550 VDD.n67 VDD.t145 0.228
R551 VDD.n67 VDD.t143 0.228
R552 VDD.n80 VDD.t15 0.228
R553 VDD.n80 VDD.t127 0.228
R554 VDD.n78 VDD.t47 0.228
R555 VDD.n78 VDD.t17 0.228
R556 VDD.n76 VDD.t109 0.228
R557 VDD.n76 VDD.t49 0.228
R558 VDD.n75 VDD.t35 0.228
R559 VDD.n75 VDD.t111 0.228
R560 VDD.n88 VDD.t167 0.228
R561 VDD.n88 VDD.t165 0.228
R562 VDD.n86 VDD.t171 0.228
R563 VDD.n86 VDD.t169 0.228
R564 VDD.n84 VDD.t101 0.228
R565 VDD.n84 VDD.t99 0.228
R566 VDD.n83 VDD.t97 0.228
R567 VDD.n83 VDD.t95 0.228
R568 VDD.n91 VDD.t85 0.228
R569 VDD.n91 VDD.t93 0.228
R570 VDD.n94 VDD.t189 0.228
R571 VDD.n94 VDD.t195 0.228
R572 VDD.n93 VDD.t191 0.228
R573 VDD.n93 VDD.t193 0.228
R574 VDD.n98 VDD.t91 0.228
R575 VDD.n98 VDD.t83 0.228
R576 VDD.n97 VDD.t87 0.228
R577 VDD.n97 VDD.t89 0.228
R578 VDD.n14 VDD.t5 0.228
R579 VDD.n14 VDD.t25 0.228
R580 VDD.n12 VDD.t41 0.228
R581 VDD.n12 VDD.t7 0.228
R582 VDD.n10 VDD.t65 0.228
R583 VDD.n10 VDD.t43 0.228
R584 VDD.n8 VDD.t21 0.228
R585 VDD.n8 VDD.t67 0.228
R586 VDD.n6 VDD.t1 0.228
R587 VDD.n6 VDD.t23 0.228
R588 VDD.n4 VDD.t37 0.228
R589 VDD.n4 VDD.t3 0.228
R590 VDD.n2 VDD.t61 0.228
R591 VDD.n2 VDD.t39 0.228
R592 VDD.n1 VDD.t19 0.228
R593 VDD.n1 VDD.t63 0.228
R594 VDD.n21 VDD.t73 0.228
R595 VDD.n21 VDD.t51 0.228
R596 VDD.n19 VDD.t149 0.228
R597 VDD.n19 VDD.t75 0.228
R598 VDD.n17 VDD.t77 0.228
R599 VDD.n17 VDD.t151 0.228
R600 VDD.n16 VDD.t103 0.228
R601 VDD.n16 VDD.t79 0.228
R602 VDD.n29 VDD.t11 0.228
R603 VDD.n29 VDD.t9 0.228
R604 VDD.n27 VDD.t155 0.228
R605 VDD.n27 VDD.t153 0.228
R606 VDD.n25 VDD.t123 0.228
R607 VDD.n25 VDD.t121 0.228
R608 VDD.n24 VDD.t141 0.228
R609 VDD.n24 VDD.t139 0.228
R610 VDD.n37 VDD.t69 0.228
R611 VDD.n37 VDD.t81 0.228
R612 VDD.n35 VDD.t27 0.228
R613 VDD.n35 VDD.t71 0.228
R614 VDD.n33 VDD.t185 0.228
R615 VDD.n33 VDD.t29 0.228
R616 VDD.n32 VDD.t133 0.228
R617 VDD.n32 VDD.t187 0.228
R618 VDD.n40 VDD.t181 0.228
R619 VDD.n40 VDD.t175 0.228
R620 VDD.n43 VDD.t115 0.228
R621 VDD.n43 VDD.t119 0.228
R622 VDD.n42 VDD.t113 0.228
R623 VDD.n42 VDD.t117 0.228
R624 VDD.n47 VDD.t183 0.228
R625 VDD.n47 VDD.t173 0.228
R626 VDD.n46 VDD.t177 0.228
R627 VDD.n46 VDD.t179 0.228
R628 VDD.n96 VDD.n92 0.2021
R629 VDD.n45 VDD.n41 0.2021
R630 VDD.n56 VDD.n54 0.189974
R631 VDD.n58 VDD.n56 0.189974
R632 VDD.n60 VDD.n58 0.189974
R633 VDD.n62 VDD.n60 0.189974
R634 VDD.n64 VDD.n62 0.189974
R635 VDD.n66 VDD.n64 0.189974
R636 VDD.n71 VDD.n69 0.189974
R637 VDD.n73 VDD.n71 0.189974
R638 VDD.n79 VDD.n77 0.189974
R639 VDD.n81 VDD.n79 0.189974
R640 VDD.n87 VDD.n85 0.189974
R641 VDD.n89 VDD.n87 0.189974
R642 VDD.n5 VDD.n3 0.189974
R643 VDD.n7 VDD.n5 0.189974
R644 VDD.n9 VDD.n7 0.189974
R645 VDD.n11 VDD.n9 0.189974
R646 VDD.n13 VDD.n11 0.189974
R647 VDD.n15 VDD.n13 0.189974
R648 VDD.n20 VDD.n18 0.189974
R649 VDD.n22 VDD.n20 0.189974
R650 VDD.n28 VDD.n26 0.189974
R651 VDD.n30 VDD.n28 0.189974
R652 VDD.n36 VDD.n34 0.189974
R653 VDD.n38 VDD.n36 0.189974
R654 VDD.n104 VDD.n0 0.020105
R655 VDD.n103 VDD.n102 0.0054955
R656 VDD.n103 VDD.n51 0.0054955
R657 VSS.n59 VSS.n58 5121.21
R658 VSS.n111 VSS.n59 5121.21
R659 VSS.n56 VSS.n55 4481.41
R660 VSS.n112 VSS.n111 4318.83
R661 VSS.n57 VSS.n56 3545.45
R662 VSS.n58 VSS.n57 3545.45
R663 VSS.t154 VSS.t118 1481.56
R664 VSS.t122 VSS.t158 1481.56
R665 VSS.t156 VSS.t102 1481.56
R666 VSS.t48 VSS.t82 1481.56
R667 VSS.t8 VSS.t68 1481.56
R668 VSS.t6 VSS.t30 1481.56
R669 VSS.t106 VSS.t172 1481.56
R670 VSS.t178 VSS.t108 1481.56
R671 VSS.t104 VSS.t28 1481.56
R672 VSS.t188 VSS.t126 1481.56
R673 VSS.t22 VSS.t140 1481.56
R674 VSS.t58 VSS.t124 1481.56
R675 VSS.n4 VSS.t160 1285.47
R676 VSS.n110 VSS.t110 1285.47
R677 VSS.n57 VSS.n3 933.951
R678 VSS.n58 VSS.n2 933.951
R679 VSS.n56 VSS.n4 907.822
R680 VSS.n111 VSS.n110 907.822
R681 VSS.n113 VSS.n59 391.87
R682 VSS.t160 VSS.t162 145.251
R683 VSS.t162 VSS.t164 145.251
R684 VSS.t164 VSS.t154 145.251
R685 VSS.t118 VSS.t120 145.251
R686 VSS.t120 VSS.t116 145.251
R687 VSS.t116 VSS.t122 145.251
R688 VSS.t158 VSS.t156 145.251
R689 VSS.t102 VSS.t198 145.251
R690 VSS.t198 VSS.t196 145.251
R691 VSS.t196 VSS.t182 145.251
R692 VSS.t182 VSS.t180 145.251
R693 VSS.t180 VSS.t144 145.251
R694 VSS.t144 VSS.t142 145.251
R695 VSS.t142 VSS.t48 145.251
R696 VSS.t82 VSS.t80 145.251
R697 VSS.t80 VSS.t72 145.251
R698 VSS.t72 VSS.t70 145.251
R699 VSS.t70 VSS.t46 145.251
R700 VSS.t46 VSS.t44 145.251
R701 VSS.t44 VSS.t10 145.251
R702 VSS.t10 VSS.t8 145.251
R703 VSS.t68 VSS.t42 145.251
R704 VSS.t42 VSS.t4 145.251
R705 VSS.t4 VSS.t148 145.251
R706 VSS.t148 VSS.t194 145.251
R707 VSS.t194 VSS.t40 145.251
R708 VSS.t40 VSS.t38 145.251
R709 VSS.t38 VSS.t6 145.251
R710 VSS.t30 VSS.t92 145.251
R711 VSS.t92 VSS.t90 145.251
R712 VSS.t90 VSS.t100 145.251
R713 VSS.t100 VSS.t98 145.251
R714 VSS.t98 VSS.t52 145.251
R715 VSS.t52 VSS.t50 145.251
R716 VSS.t50 VSS.t2 145.251
R717 VSS.t2 VSS.t0 145.251
R718 VSS.t0 VSS.t34 145.251
R719 VSS.t34 VSS.t32 145.251
R720 VSS.t32 VSS.t96 145.251
R721 VSS.t96 VSS.t94 145.251
R722 VSS.t94 VSS.t152 145.251
R723 VSS.t152 VSS.t150 145.251
R724 VSS.t150 VSS.t36 145.251
R725 VSS.t110 VSS.t112 145.251
R726 VSS.t112 VSS.t114 145.251
R727 VSS.t114 VSS.t106 145.251
R728 VSS.t172 VSS.t174 145.251
R729 VSS.t174 VSS.t176 145.251
R730 VSS.t176 VSS.t178 145.251
R731 VSS.t108 VSS.t104 145.251
R732 VSS.t28 VSS.t26 145.251
R733 VSS.t26 VSS.t88 145.251
R734 VSS.t88 VSS.t86 145.251
R735 VSS.t86 VSS.t78 145.251
R736 VSS.t78 VSS.t76 145.251
R737 VSS.t76 VSS.t170 145.251
R738 VSS.t170 VSS.t188 145.251
R739 VSS.t126 VSS.t62 145.251
R740 VSS.t62 VSS.t60 145.251
R741 VSS.t60 VSS.t20 145.251
R742 VSS.t20 VSS.t18 145.251
R743 VSS.t18 VSS.t66 145.251
R744 VSS.t66 VSS.t64 145.251
R745 VSS.t64 VSS.t22 145.251
R746 VSS.t140 VSS.t146 145.251
R747 VSS.t146 VSS.t16 145.251
R748 VSS.t16 VSS.t74 145.251
R749 VSS.t74 VSS.t24 145.251
R750 VSS.t24 VSS.t56 145.251
R751 VSS.t56 VSS.t54 145.251
R752 VSS.t54 VSS.t58 145.251
R753 VSS.t124 VSS.t186 145.251
R754 VSS.t186 VSS.t184 145.251
R755 VSS.t184 VSS.t130 145.251
R756 VSS.t130 VSS.t128 145.251
R757 VSS.t128 VSS.t134 145.251
R758 VSS.t134 VSS.t132 145.251
R759 VSS.t132 VSS.t192 145.251
R760 VSS.t192 VSS.t190 145.251
R761 VSS.t190 VSS.t138 145.251
R762 VSS.t138 VSS.t136 145.251
R763 VSS.t136 VSS.t168 145.251
R764 VSS.t168 VSS.t166 145.251
R765 VSS.t166 VSS.t14 145.251
R766 VSS.t14 VSS.t12 145.251
R767 VSS.t12 VSS.t84 145.251
R768 VSS.n54 VSS.n4 24.2224
R769 VSS.n110 VSS.n109 24.2224
R770 VSS.n45 VSS.n44 15.3617
R771 VSS.n100 VSS.n99 15.3617
R772 VSS.n27 VSS.n19 10.4304
R773 VSS.n82 VSS.n74 10.4304
R774 VSS.n27 VSS.n26 9.9768
R775 VSS.n35 VSS.n34 9.9768
R776 VSS.n43 VSS.n42 9.9768
R777 VSS.n49 VSS.n48 9.9768
R778 VSS.n53 VSS.n52 9.9768
R779 VSS.n82 VSS.n81 9.9768
R780 VSS.n90 VSS.n89 9.9768
R781 VSS.n98 VSS.n97 9.9768
R782 VSS.n104 VSS.n103 9.9768
R783 VSS.n108 VSS.n107 9.9768
R784 VSS.n7 VSS.n5 5.57485
R785 VSS.n22 VSS.n20 5.57485
R786 VSS.n30 VSS.n28 5.57485
R787 VSS.n38 VSS.n36 5.57485
R788 VSS.n48 VSS.n46 5.57485
R789 VSS.n52 VSS.n50 5.57485
R790 VSS.n62 VSS.n60 5.57485
R791 VSS.n77 VSS.n75 5.57485
R792 VSS.n85 VSS.n83 5.57485
R793 VSS.n93 VSS.n91 5.57485
R794 VSS.n103 VSS.n101 5.57485
R795 VSS.n107 VSS.n105 5.57485
R796 VSS.n19 VSS.n18 5.38537
R797 VSS.n17 VSS.n16 5.38537
R798 VSS.n15 VSS.n14 5.38537
R799 VSS.n13 VSS.n12 5.38537
R800 VSS.n11 VSS.n10 5.38537
R801 VSS.n9 VSS.n8 5.38537
R802 VSS.n7 VSS.n6 5.38537
R803 VSS.n26 VSS.n25 5.38537
R804 VSS.n24 VSS.n23 5.38537
R805 VSS.n22 VSS.n21 5.38537
R806 VSS.n34 VSS.n33 5.38537
R807 VSS.n32 VSS.n31 5.38537
R808 VSS.n30 VSS.n29 5.38537
R809 VSS.n42 VSS.n41 5.38537
R810 VSS.n40 VSS.n39 5.38537
R811 VSS.n38 VSS.n37 5.38537
R812 VSS.n48 VSS.n47 5.38537
R813 VSS.n52 VSS.n51 5.38537
R814 VSS.n74 VSS.n73 5.38537
R815 VSS.n72 VSS.n71 5.38537
R816 VSS.n70 VSS.n69 5.38537
R817 VSS.n68 VSS.n67 5.38537
R818 VSS.n66 VSS.n65 5.38537
R819 VSS.n64 VSS.n63 5.38537
R820 VSS.n62 VSS.n61 5.38537
R821 VSS.n81 VSS.n80 5.38537
R822 VSS.n79 VSS.n78 5.38537
R823 VSS.n77 VSS.n76 5.38537
R824 VSS.n89 VSS.n88 5.38537
R825 VSS.n87 VSS.n86 5.38537
R826 VSS.n85 VSS.n84 5.38537
R827 VSS.n97 VSS.n96 5.38537
R828 VSS.n95 VSS.n94 5.38537
R829 VSS.n93 VSS.n92 5.38537
R830 VSS.n103 VSS.n102 5.38537
R831 VSS.n107 VSS.n106 5.38537
R832 VSS.n1 VSS.n0 4.5005
R833 VSS.n114 VSS.n0 4.5005
R834 VSS.n116 VSS.n115 2.26839
R835 VSS.n55 VSS.n54 1.90847
R836 VSS.n112 VSS.n109 1.90847
R837 VSS VSS.n116 1.13544
R838 VSS.n55 VSS.n3 0.543479
R839 VSS.n3 VSS.n2 0.543479
R840 VSS.n113 VSS.n112 0.543479
R841 VSS.n2 VSS.n1 0.507615
R842 VSS.n114 VSS.n113 0.507363
R843 VSS.n45 VSS.n43 0.3101
R844 VSS.n43 VSS.n35 0.3101
R845 VSS.n35 VSS.n27 0.3101
R846 VSS.n100 VSS.n98 0.3101
R847 VSS.n98 VSS.n90 0.3101
R848 VSS.n90 VSS.n82 0.3101
R849 VSS.n54 VSS.n53 0.244205
R850 VSS.n109 VSS.n108 0.244205
R851 VSS.n53 VSS.n49 0.2381
R852 VSS.n108 VSS.n104 0.2381
R853 VSS.n18 VSS.t151 0.20525
R854 VSS.n18 VSS.t37 0.20525
R855 VSS.n16 VSS.t95 0.20525
R856 VSS.n16 VSS.t153 0.20525
R857 VSS.n14 VSS.t33 0.20525
R858 VSS.n14 VSS.t97 0.20525
R859 VSS.n12 VSS.t1 0.20525
R860 VSS.n12 VSS.t35 0.20525
R861 VSS.n10 VSS.t51 0.20525
R862 VSS.n10 VSS.t3 0.20525
R863 VSS.n8 VSS.t99 0.20525
R864 VSS.n8 VSS.t53 0.20525
R865 VSS.n6 VSS.t91 0.20525
R866 VSS.n6 VSS.t101 0.20525
R867 VSS.n5 VSS.t31 0.20525
R868 VSS.n5 VSS.t93 0.20525
R869 VSS.n25 VSS.t39 0.20525
R870 VSS.n25 VSS.t7 0.20525
R871 VSS.n23 VSS.t195 0.20525
R872 VSS.n23 VSS.t41 0.20525
R873 VSS.n21 VSS.t5 0.20525
R874 VSS.n21 VSS.t149 0.20525
R875 VSS.n20 VSS.t69 0.20525
R876 VSS.n20 VSS.t43 0.20525
R877 VSS.n33 VSS.t11 0.20525
R878 VSS.n33 VSS.t9 0.20525
R879 VSS.n31 VSS.t47 0.20525
R880 VSS.n31 VSS.t45 0.20525
R881 VSS.n29 VSS.t73 0.20525
R882 VSS.n29 VSS.t71 0.20525
R883 VSS.n28 VSS.t83 0.20525
R884 VSS.n28 VSS.t81 0.20525
R885 VSS.n41 VSS.t143 0.20525
R886 VSS.n41 VSS.t49 0.20525
R887 VSS.n39 VSS.t181 0.20525
R888 VSS.n39 VSS.t145 0.20525
R889 VSS.n37 VSS.t197 0.20525
R890 VSS.n37 VSS.t183 0.20525
R891 VSS.n36 VSS.t103 0.20525
R892 VSS.n36 VSS.t199 0.20525
R893 VSS.n44 VSS.t159 0.20525
R894 VSS.n44 VSS.t157 0.20525
R895 VSS.n47 VSS.t117 0.20525
R896 VSS.n47 VSS.t123 0.20525
R897 VSS.n46 VSS.t119 0.20525
R898 VSS.n46 VSS.t121 0.20525
R899 VSS.n51 VSS.t165 0.20525
R900 VSS.n51 VSS.t155 0.20525
R901 VSS.n50 VSS.t161 0.20525
R902 VSS.n50 VSS.t163 0.20525
R903 VSS.n73 VSS.t13 0.20525
R904 VSS.n73 VSS.t85 0.20525
R905 VSS.n71 VSS.t167 0.20525
R906 VSS.n71 VSS.t15 0.20525
R907 VSS.n69 VSS.t137 0.20525
R908 VSS.n69 VSS.t169 0.20525
R909 VSS.n67 VSS.t191 0.20525
R910 VSS.n67 VSS.t139 0.20525
R911 VSS.n65 VSS.t133 0.20525
R912 VSS.n65 VSS.t193 0.20525
R913 VSS.n63 VSS.t129 0.20525
R914 VSS.n63 VSS.t135 0.20525
R915 VSS.n61 VSS.t185 0.20525
R916 VSS.n61 VSS.t131 0.20525
R917 VSS.n60 VSS.t125 0.20525
R918 VSS.n60 VSS.t187 0.20525
R919 VSS.n80 VSS.t55 0.20525
R920 VSS.n80 VSS.t59 0.20525
R921 VSS.n78 VSS.t25 0.20525
R922 VSS.n78 VSS.t57 0.20525
R923 VSS.n76 VSS.t17 0.20525
R924 VSS.n76 VSS.t75 0.20525
R925 VSS.n75 VSS.t141 0.20525
R926 VSS.n75 VSS.t147 0.20525
R927 VSS.n88 VSS.t65 0.20525
R928 VSS.n88 VSS.t23 0.20525
R929 VSS.n86 VSS.t19 0.20525
R930 VSS.n86 VSS.t67 0.20525
R931 VSS.n84 VSS.t61 0.20525
R932 VSS.n84 VSS.t21 0.20525
R933 VSS.n83 VSS.t127 0.20525
R934 VSS.n83 VSS.t63 0.20525
R935 VSS.n96 VSS.t171 0.20525
R936 VSS.n96 VSS.t189 0.20525
R937 VSS.n94 VSS.t79 0.20525
R938 VSS.n94 VSS.t77 0.20525
R939 VSS.n92 VSS.t89 0.20525
R940 VSS.n92 VSS.t87 0.20525
R941 VSS.n91 VSS.t29 0.20525
R942 VSS.n91 VSS.t27 0.20525
R943 VSS.n99 VSS.t109 0.20525
R944 VSS.n99 VSS.t105 0.20525
R945 VSS.n102 VSS.t177 0.20525
R946 VSS.n102 VSS.t179 0.20525
R947 VSS.n101 VSS.t173 0.20525
R948 VSS.n101 VSS.t175 0.20525
R949 VSS.n106 VSS.t115 0.20525
R950 VSS.n106 VSS.t107 0.20525
R951 VSS.n105 VSS.t111 0.20525
R952 VSS.n105 VSS.t113 0.20525
R953 VSS.n49 VSS.n45 0.2021
R954 VSS.n104 VSS.n100 0.2021
R955 VSS.n9 VSS.n7 0.189974
R956 VSS.n11 VSS.n9 0.189974
R957 VSS.n13 VSS.n11 0.189974
R958 VSS.n15 VSS.n13 0.189974
R959 VSS.n17 VSS.n15 0.189974
R960 VSS.n19 VSS.n17 0.189974
R961 VSS.n24 VSS.n22 0.189974
R962 VSS.n26 VSS.n24 0.189974
R963 VSS.n32 VSS.n30 0.189974
R964 VSS.n34 VSS.n32 0.189974
R965 VSS.n40 VSS.n38 0.189974
R966 VSS.n42 VSS.n40 0.189974
R967 VSS.n64 VSS.n62 0.189974
R968 VSS.n66 VSS.n64 0.189974
R969 VSS.n68 VSS.n66 0.189974
R970 VSS.n70 VSS.n68 0.189974
R971 VSS.n72 VSS.n70 0.189974
R972 VSS.n74 VSS.n72 0.189974
R973 VSS.n79 VSS.n77 0.189974
R974 VSS.n81 VSS.n79 0.189974
R975 VSS.n87 VSS.n85 0.189974
R976 VSS.n89 VSS.n87 0.189974
R977 VSS.n95 VSS.n93 0.189974
R978 VSS.n97 VSS.n95 0.189974
R979 VSS.n116 VSS.n0 0.020105
R980 VSS.n115 VSS.n114 0.0054955
R981 VSS.n115 VSS.n1 0.0054955
R982 a_14220_6400.n46 a_14220_6400.t31 113.632
R983 a_14220_6400.n56 a_14220_6400.t16 113.632
R984 a_14220_6400.n17 a_14220_6400.t47 113.632
R985 a_14220_6400.n27 a_14220_6400.t32 113.632
R986 a_14220_6400.n65 a_14220_6400.t23 109.174
R987 a_14220_6400.n66 a_14220_6400.t24 109.174
R988 a_14220_6400.n47 a_14220_6400.t30 109.174
R989 a_14220_6400.n48 a_14220_6400.t29 109.174
R990 a_14220_6400.n49 a_14220_6400.t28 109.174
R991 a_14220_6400.n50 a_14220_6400.t27 109.174
R992 a_14220_6400.n51 a_14220_6400.t26 109.174
R993 a_14220_6400.n52 a_14220_6400.t25 109.174
R994 a_14220_6400.n64 a_14220_6400.t22 109.174
R995 a_14220_6400.n53 a_14220_6400.t21 109.174
R996 a_14220_6400.n60 a_14220_6400.t20 109.174
R997 a_14220_6400.n59 a_14220_6400.t19 109.174
R998 a_14220_6400.n58 a_14220_6400.t18 109.174
R999 a_14220_6400.n55 a_14220_6400.t17 109.174
R1000 a_14220_6400.n36 a_14220_6400.t39 109.174
R1001 a_14220_6400.n37 a_14220_6400.t40 109.174
R1002 a_14220_6400.n18 a_14220_6400.t46 109.174
R1003 a_14220_6400.n19 a_14220_6400.t45 109.174
R1004 a_14220_6400.n20 a_14220_6400.t44 109.174
R1005 a_14220_6400.n21 a_14220_6400.t43 109.174
R1006 a_14220_6400.n22 a_14220_6400.t42 109.174
R1007 a_14220_6400.n23 a_14220_6400.t41 109.174
R1008 a_14220_6400.n35 a_14220_6400.t38 109.174
R1009 a_14220_6400.n24 a_14220_6400.t37 109.174
R1010 a_14220_6400.n31 a_14220_6400.t36 109.174
R1011 a_14220_6400.n30 a_14220_6400.t35 109.174
R1012 a_14220_6400.n29 a_14220_6400.t34 109.174
R1013 a_14220_6400.n26 a_14220_6400.t33 109.174
R1014 a_14220_6400.n65 a_14220_6400.n40 18.4942
R1015 a_14220_6400.n67 a_14220_6400.n66 18.4942
R1016 a_14220_6400.n48 a_14220_6400.n45 18.4942
R1017 a_14220_6400.n49 a_14220_6400.n44 18.4942
R1018 a_14220_6400.n50 a_14220_6400.n43 18.4942
R1019 a_14220_6400.n51 a_14220_6400.n42 18.4942
R1020 a_14220_6400.n52 a_14220_6400.n41 18.4942
R1021 a_14220_6400.n64 a_14220_6400.n63 18.4942
R1022 a_14220_6400.n62 a_14220_6400.n53 18.4942
R1023 a_14220_6400.n61 a_14220_6400.n60 18.4942
R1024 a_14220_6400.n59 a_14220_6400.n54 18.4942
R1025 a_14220_6400.n58 a_14220_6400.n57 18.4942
R1026 a_14220_6400.n36 a_14220_6400.n11 18.4942
R1027 a_14220_6400.n38 a_14220_6400.n37 18.4942
R1028 a_14220_6400.n19 a_14220_6400.n16 18.4942
R1029 a_14220_6400.n20 a_14220_6400.n15 18.4942
R1030 a_14220_6400.n21 a_14220_6400.n14 18.4942
R1031 a_14220_6400.n22 a_14220_6400.n13 18.4942
R1032 a_14220_6400.n23 a_14220_6400.n12 18.4942
R1033 a_14220_6400.n35 a_14220_6400.n34 18.4942
R1034 a_14220_6400.n33 a_14220_6400.n24 18.4942
R1035 a_14220_6400.n32 a_14220_6400.n31 18.4942
R1036 a_14220_6400.n30 a_14220_6400.n25 18.4942
R1037 a_14220_6400.n29 a_14220_6400.n28 18.4942
R1038 a_14220_6400.n70 a_14220_6400.n69 14.1358
R1039 a_14220_6400.n65 a_14220_6400.n64 11.6805
R1040 a_14220_6400.n66 a_14220_6400.n65 11.6805
R1041 a_14220_6400.n48 a_14220_6400.n47 11.6805
R1042 a_14220_6400.n49 a_14220_6400.n48 11.6805
R1043 a_14220_6400.n50 a_14220_6400.n49 11.6805
R1044 a_14220_6400.n51 a_14220_6400.n50 11.6805
R1045 a_14220_6400.n52 a_14220_6400.n51 11.6805
R1046 a_14220_6400.n66 a_14220_6400.n52 11.6805
R1047 a_14220_6400.n64 a_14220_6400.n53 11.6805
R1048 a_14220_6400.n60 a_14220_6400.n53 11.6805
R1049 a_14220_6400.n60 a_14220_6400.n59 11.6805
R1050 a_14220_6400.n59 a_14220_6400.n58 11.6805
R1051 a_14220_6400.n58 a_14220_6400.n55 11.6805
R1052 a_14220_6400.n36 a_14220_6400.n35 11.6805
R1053 a_14220_6400.n37 a_14220_6400.n36 11.6805
R1054 a_14220_6400.n19 a_14220_6400.n18 11.6805
R1055 a_14220_6400.n20 a_14220_6400.n19 11.6805
R1056 a_14220_6400.n21 a_14220_6400.n20 11.6805
R1057 a_14220_6400.n22 a_14220_6400.n21 11.6805
R1058 a_14220_6400.n23 a_14220_6400.n22 11.6805
R1059 a_14220_6400.n37 a_14220_6400.n23 11.6805
R1060 a_14220_6400.n35 a_14220_6400.n24 11.6805
R1061 a_14220_6400.n31 a_14220_6400.n24 11.6805
R1062 a_14220_6400.n31 a_14220_6400.n30 11.6805
R1063 a_14220_6400.n30 a_14220_6400.n29 11.6805
R1064 a_14220_6400.n29 a_14220_6400.n26 11.6805
R1065 a_14220_6400.n69 a_14220_6400.n39 10.688
R1066 a_14220_6400.n69 a_14220_6400.n68 9.24157
R1067 a_14220_6400.n57 a_14220_6400.n56 7.17687
R1068 a_14220_6400.n46 a_14220_6400.n45 7.17687
R1069 a_14220_6400.n28 a_14220_6400.n27 7.17687
R1070 a_14220_6400.n17 a_14220_6400.n16 7.17687
R1071 a_14220_6400.n70 a_14220_6400.n10 6.5392
R1072 a_14220_6400.n1 a_14220_6400.t1 5.7796
R1073 a_14220_6400.n5 a_14220_6400.t5 5.73764
R1074 a_14220_6400.n71 a_14220_6400.t6 5.59012
R1075 a_14220_6400.n10 a_14220_6400.t11 5.54817
R1076 a_14220_6400.n73 a_14220_6400.n72 5.38537
R1077 a_14220_6400.n1 a_14220_6400.n0 5.38537
R1078 a_14220_6400.n3 a_14220_6400.n2 5.38537
R1079 a_14220_6400.n5 a_14220_6400.n4 5.32067
R1080 a_14220_6400.n7 a_14220_6400.n6 5.32067
R1081 a_14220_6400.n9 a_14220_6400.n8 5.32067
R1082 a_14220_6400.n71 a_14220_6400.n70 4.61063
R1083 a_14220_6400.n47 a_14220_6400.n46 4.42851
R1084 a_14220_6400.n56 a_14220_6400.n55 4.42851
R1085 a_14220_6400.n18 a_14220_6400.n17 4.42851
R1086 a_14220_6400.n27 a_14220_6400.n26 4.42851
R1087 a_14220_6400.n4 a_14220_6400.t8 0.228
R1088 a_14220_6400.n4 a_14220_6400.t7 0.228
R1089 a_14220_6400.n6 a_14220_6400.t13 0.228
R1090 a_14220_6400.n6 a_14220_6400.t12 0.228
R1091 a_14220_6400.n8 a_14220_6400.t10 0.228
R1092 a_14220_6400.n8 a_14220_6400.t9 0.228
R1093 a_14220_6400.n73 a_14220_6400.t4 0.20525
R1094 a_14220_6400.t0 a_14220_6400.n73 0.20525
R1095 a_14220_6400.n0 a_14220_6400.t3 0.20525
R1096 a_14220_6400.n0 a_14220_6400.t2 0.20525
R1097 a_14220_6400.n2 a_14220_6400.t14 0.20525
R1098 a_14220_6400.n2 a_14220_6400.t15 0.20525
R1099 a_14220_6400.n72 a_14220_6400.n71 0.189974
R1100 a_14220_6400.n72 a_14220_6400.n3 0.189974
R1101 a_14220_6400.n3 a_14220_6400.n1 0.189974
R1102 a_14220_6400.n10 a_14220_6400.n9 0.189974
R1103 a_14220_6400.n9 a_14220_6400.n7 0.189974
R1104 a_14220_6400.n7 a_14220_6400.n5 0.189974
R1105 a_14220_6400.n63 a_14220_6400.n40 0.1205
R1106 a_14220_6400.n63 a_14220_6400.n62 0.1205
R1107 a_14220_6400.n62 a_14220_6400.n61 0.1205
R1108 a_14220_6400.n61 a_14220_6400.n54 0.1205
R1109 a_14220_6400.n57 a_14220_6400.n54 0.1205
R1110 a_14220_6400.n45 a_14220_6400.n44 0.1205
R1111 a_14220_6400.n44 a_14220_6400.n43 0.1205
R1112 a_14220_6400.n43 a_14220_6400.n42 0.1205
R1113 a_14220_6400.n42 a_14220_6400.n41 0.1205
R1114 a_14220_6400.n67 a_14220_6400.n41 0.1205
R1115 a_14220_6400.n34 a_14220_6400.n11 0.1205
R1116 a_14220_6400.n34 a_14220_6400.n33 0.1205
R1117 a_14220_6400.n33 a_14220_6400.n32 0.1205
R1118 a_14220_6400.n32 a_14220_6400.n25 0.1205
R1119 a_14220_6400.n28 a_14220_6400.n25 0.1205
R1120 a_14220_6400.n16 a_14220_6400.n15 0.1205
R1121 a_14220_6400.n15 a_14220_6400.n14 0.1205
R1122 a_14220_6400.n14 a_14220_6400.n13 0.1205
R1123 a_14220_6400.n13 a_14220_6400.n12 0.1205
R1124 a_14220_6400.n38 a_14220_6400.n12 0.1205
R1125 a_14220_6400.n68 a_14220_6400.n40 0.0485
R1126 a_14220_6400.n68 a_14220_6400.n67 0.0485
R1127 a_14220_6400.n39 a_14220_6400.n11 0.0485
R1128 a_14220_6400.n39 a_14220_6400.n38 0.0485
R1129 a_6924_6400.n15 a_6924_6400.t11 113.632
R1130 a_6924_6400.n19 a_6924_6400.t4 113.632
R1131 a_6924_6400.n2 a_6924_6400.t19 113.632
R1132 a_6924_6400.n6 a_6924_6400.t12 113.632
R1133 a_6924_6400.n22 a_6924_6400.t7 109.174
R1134 a_6924_6400.n23 a_6924_6400.t8 109.174
R1135 a_6924_6400.n16 a_6924_6400.t10 109.174
R1136 a_6924_6400.n17 a_6924_6400.t9 109.174
R1137 a_6924_6400.n21 a_6924_6400.t6 109.174
R1138 a_6924_6400.n18 a_6924_6400.t5 109.174
R1139 a_6924_6400.n9 a_6924_6400.t15 109.174
R1140 a_6924_6400.n10 a_6924_6400.t16 109.174
R1141 a_6924_6400.n3 a_6924_6400.t18 109.174
R1142 a_6924_6400.n4 a_6924_6400.t17 109.174
R1143 a_6924_6400.n8 a_6924_6400.t14 109.174
R1144 a_6924_6400.n5 a_6924_6400.t13 109.174
R1145 a_6924_6400.n22 a_6924_6400.n13 18.4942
R1146 a_6924_6400.n24 a_6924_6400.n23 18.4942
R1147 a_6924_6400.n17 a_6924_6400.n14 18.4942
R1148 a_6924_6400.n21 a_6924_6400.n20 18.4942
R1149 a_6924_6400.n9 a_6924_6400.n0 18.4942
R1150 a_6924_6400.n11 a_6924_6400.n10 18.4942
R1151 a_6924_6400.n4 a_6924_6400.n1 18.4942
R1152 a_6924_6400.n8 a_6924_6400.n7 18.4942
R1153 a_6924_6400.n28 a_6924_6400.n26 17.2799
R1154 a_6924_6400.n22 a_6924_6400.n21 11.6805
R1155 a_6924_6400.n23 a_6924_6400.n22 11.6805
R1156 a_6924_6400.n17 a_6924_6400.n16 11.6805
R1157 a_6924_6400.n23 a_6924_6400.n17 11.6805
R1158 a_6924_6400.n21 a_6924_6400.n18 11.6805
R1159 a_6924_6400.n9 a_6924_6400.n8 11.6805
R1160 a_6924_6400.n10 a_6924_6400.n9 11.6805
R1161 a_6924_6400.n4 a_6924_6400.n3 11.6805
R1162 a_6924_6400.n10 a_6924_6400.n4 11.6805
R1163 a_6924_6400.n8 a_6924_6400.n5 11.6805
R1164 a_6924_6400.n26 a_6924_6400.n12 10.013
R1165 a_6924_6400.n26 a_6924_6400.n25 9.91657
R1166 a_6924_6400.n20 a_6924_6400.n19 7.17687
R1167 a_6924_6400.n15 a_6924_6400.n14 7.17687
R1168 a_6924_6400.n7 a_6924_6400.n6 7.17687
R1169 a_6924_6400.n2 a_6924_6400.n1 7.17687
R1170 a_6924_6400.n29 a_6924_6400.n28 6.5392
R1171 a_6924_6400.n27 a_6924_6400.t3 5.7796
R1172 a_6924_6400.t1 a_6924_6400.n29 5.73764
R1173 a_6924_6400.n27 a_6924_6400.t2 5.59012
R1174 a_6924_6400.n29 a_6924_6400.t0 5.54817
R1175 a_6924_6400.n28 a_6924_6400.n27 4.61063
R1176 a_6924_6400.n16 a_6924_6400.n15 4.42851
R1177 a_6924_6400.n19 a_6924_6400.n18 4.42851
R1178 a_6924_6400.n3 a_6924_6400.n2 4.42851
R1179 a_6924_6400.n6 a_6924_6400.n5 4.42851
R1180 a_6924_6400.n20 a_6924_6400.n13 0.1205
R1181 a_6924_6400.n24 a_6924_6400.n14 0.1205
R1182 a_6924_6400.n7 a_6924_6400.n0 0.1205
R1183 a_6924_6400.n11 a_6924_6400.n1 0.1205
R1184 a_6924_6400.n25 a_6924_6400.n13 0.0485
R1185 a_6924_6400.n25 a_6924_6400.n24 0.0485
R1186 a_6924_6400.n12 a_6924_6400.n0 0.0485
R1187 a_6924_6400.n12 a_6924_6400.n11 0.0485
R1188 a_4812_6400.n15 a_4812_6400.t15 113.632
R1189 a_4812_6400.n19 a_4812_6400.t8 113.632
R1190 a_4812_6400.n2 a_4812_6400.t23 113.632
R1191 a_4812_6400.n6 a_4812_6400.t16 113.632
R1192 a_4812_6400.n22 a_4812_6400.t11 109.174
R1193 a_4812_6400.n23 a_4812_6400.t12 109.174
R1194 a_4812_6400.n16 a_4812_6400.t14 109.174
R1195 a_4812_6400.n17 a_4812_6400.t13 109.174
R1196 a_4812_6400.n21 a_4812_6400.t10 109.174
R1197 a_4812_6400.n18 a_4812_6400.t9 109.174
R1198 a_4812_6400.n9 a_4812_6400.t19 109.174
R1199 a_4812_6400.n10 a_4812_6400.t20 109.174
R1200 a_4812_6400.n3 a_4812_6400.t22 109.174
R1201 a_4812_6400.n4 a_4812_6400.t21 109.174
R1202 a_4812_6400.n8 a_4812_6400.t18 109.174
R1203 a_4812_6400.n5 a_4812_6400.t17 109.174
R1204 a_4812_6400.n22 a_4812_6400.n13 18.4942
R1205 a_4812_6400.n24 a_4812_6400.n23 18.4942
R1206 a_4812_6400.n17 a_4812_6400.n14 18.4942
R1207 a_4812_6400.n21 a_4812_6400.n20 18.4942
R1208 a_4812_6400.n9 a_4812_6400.n0 18.4942
R1209 a_4812_6400.n11 a_4812_6400.n10 18.4942
R1210 a_4812_6400.n4 a_4812_6400.n1 18.4942
R1211 a_4812_6400.n8 a_4812_6400.n7 18.4942
R1212 a_4812_6400.n30 a_4812_6400.n26 16.9914
R1213 a_4812_6400.n22 a_4812_6400.n21 11.6805
R1214 a_4812_6400.n23 a_4812_6400.n22 11.6805
R1215 a_4812_6400.n17 a_4812_6400.n16 11.6805
R1216 a_4812_6400.n23 a_4812_6400.n17 11.6805
R1217 a_4812_6400.n21 a_4812_6400.n18 11.6805
R1218 a_4812_6400.n9 a_4812_6400.n8 11.6805
R1219 a_4812_6400.n10 a_4812_6400.n9 11.6805
R1220 a_4812_6400.n4 a_4812_6400.n3 11.6805
R1221 a_4812_6400.n10 a_4812_6400.n4 11.6805
R1222 a_4812_6400.n8 a_4812_6400.n5 11.6805
R1223 a_4812_6400.n26 a_4812_6400.n12 10.3505
R1224 a_4812_6400.n26 a_4812_6400.n25 9.57907
R1225 a_4812_6400.n20 a_4812_6400.n19 7.17687
R1226 a_4812_6400.n15 a_4812_6400.n14 7.17687
R1227 a_4812_6400.n7 a_4812_6400.n6 7.17687
R1228 a_4812_6400.n2 a_4812_6400.n1 7.17687
R1229 a_4812_6400.n31 a_4812_6400.n30 6.5392
R1230 a_4812_6400.n28 a_4812_6400.t7 5.7796
R1231 a_4812_6400.t3 a_4812_6400.n33 5.73764
R1232 a_4812_6400.n29 a_4812_6400.t4 5.59012
R1233 a_4812_6400.n31 a_4812_6400.t0 5.54817
R1234 a_4812_6400.n28 a_4812_6400.n27 5.38537
R1235 a_4812_6400.n33 a_4812_6400.n32 5.32067
R1236 a_4812_6400.n30 a_4812_6400.n29 4.61063
R1237 a_4812_6400.n16 a_4812_6400.n15 4.42851
R1238 a_4812_6400.n19 a_4812_6400.n18 4.42851
R1239 a_4812_6400.n3 a_4812_6400.n2 4.42851
R1240 a_4812_6400.n6 a_4812_6400.n5 4.42851
R1241 a_4812_6400.n32 a_4812_6400.t1 0.228
R1242 a_4812_6400.n32 a_4812_6400.t2 0.228
R1243 a_4812_6400.n27 a_4812_6400.t5 0.20525
R1244 a_4812_6400.n27 a_4812_6400.t6 0.20525
R1245 a_4812_6400.n33 a_4812_6400.n31 0.189974
R1246 a_4812_6400.n29 a_4812_6400.n28 0.189974
R1247 a_4812_6400.n20 a_4812_6400.n13 0.1205
R1248 a_4812_6400.n24 a_4812_6400.n14 0.1205
R1249 a_4812_6400.n7 a_4812_6400.n0 0.1205
R1250 a_4812_6400.n11 a_4812_6400.n1 0.1205
R1251 a_4812_6400.n25 a_4812_6400.n13 0.0485
R1252 a_4812_6400.n25 a_4812_6400.n24 0.0485
R1253 a_4812_6400.n12 a_4812_6400.n0 0.0485
R1254 a_4812_6400.n12 a_4812_6400.n11 0.0485
R1255 a_2700_6400.n15 a_2700_6400.t15 113.632
R1256 a_2700_6400.n19 a_2700_6400.t8 113.632
R1257 a_2700_6400.n2 a_2700_6400.t23 113.632
R1258 a_2700_6400.n6 a_2700_6400.t16 113.632
R1259 a_2700_6400.n22 a_2700_6400.t11 109.174
R1260 a_2700_6400.n23 a_2700_6400.t12 109.174
R1261 a_2700_6400.n16 a_2700_6400.t14 109.174
R1262 a_2700_6400.n17 a_2700_6400.t13 109.174
R1263 a_2700_6400.n21 a_2700_6400.t10 109.174
R1264 a_2700_6400.n18 a_2700_6400.t9 109.174
R1265 a_2700_6400.n9 a_2700_6400.t19 109.174
R1266 a_2700_6400.n10 a_2700_6400.t20 109.174
R1267 a_2700_6400.n3 a_2700_6400.t22 109.174
R1268 a_2700_6400.n4 a_2700_6400.t21 109.174
R1269 a_2700_6400.n8 a_2700_6400.t18 109.174
R1270 a_2700_6400.n5 a_2700_6400.t17 109.174
R1271 a_2700_6400.n22 a_2700_6400.n13 18.4942
R1272 a_2700_6400.n24 a_2700_6400.n23 18.4942
R1273 a_2700_6400.n17 a_2700_6400.n14 18.4942
R1274 a_2700_6400.n21 a_2700_6400.n20 18.4942
R1275 a_2700_6400.n9 a_2700_6400.n0 18.4942
R1276 a_2700_6400.n11 a_2700_6400.n10 18.4942
R1277 a_2700_6400.n4 a_2700_6400.n1 18.4942
R1278 a_2700_6400.n8 a_2700_6400.n7 18.4942
R1279 a_2700_6400.n30 a_2700_6400.n26 16.7028
R1280 a_2700_6400.n22 a_2700_6400.n21 11.6805
R1281 a_2700_6400.n23 a_2700_6400.n22 11.6805
R1282 a_2700_6400.n17 a_2700_6400.n16 11.6805
R1283 a_2700_6400.n23 a_2700_6400.n17 11.6805
R1284 a_2700_6400.n21 a_2700_6400.n18 11.6805
R1285 a_2700_6400.n9 a_2700_6400.n8 11.6805
R1286 a_2700_6400.n10 a_2700_6400.n9 11.6805
R1287 a_2700_6400.n4 a_2700_6400.n3 11.6805
R1288 a_2700_6400.n10 a_2700_6400.n4 11.6805
R1289 a_2700_6400.n8 a_2700_6400.n5 11.6805
R1290 a_2700_6400.n26 a_2700_6400.n12 10.688
R1291 a_2700_6400.n26 a_2700_6400.n25 9.24157
R1292 a_2700_6400.n20 a_2700_6400.n19 7.17687
R1293 a_2700_6400.n15 a_2700_6400.n14 7.17687
R1294 a_2700_6400.n7 a_2700_6400.n6 7.17687
R1295 a_2700_6400.n2 a_2700_6400.n1 7.17687
R1296 a_2700_6400.n31 a_2700_6400.n30 6.5392
R1297 a_2700_6400.n28 a_2700_6400.t7 5.7796
R1298 a_2700_6400.t3 a_2700_6400.n33 5.73764
R1299 a_2700_6400.n29 a_2700_6400.t4 5.59012
R1300 a_2700_6400.n31 a_2700_6400.t0 5.54817
R1301 a_2700_6400.n28 a_2700_6400.n27 5.38537
R1302 a_2700_6400.n33 a_2700_6400.n32 5.32067
R1303 a_2700_6400.n30 a_2700_6400.n29 4.61063
R1304 a_2700_6400.n16 a_2700_6400.n15 4.42851
R1305 a_2700_6400.n19 a_2700_6400.n18 4.42851
R1306 a_2700_6400.n3 a_2700_6400.n2 4.42851
R1307 a_2700_6400.n6 a_2700_6400.n5 4.42851
R1308 a_2700_6400.n32 a_2700_6400.t1 0.228
R1309 a_2700_6400.n32 a_2700_6400.t2 0.228
R1310 a_2700_6400.n27 a_2700_6400.t5 0.20525
R1311 a_2700_6400.n27 a_2700_6400.t6 0.20525
R1312 a_2700_6400.n33 a_2700_6400.n31 0.189974
R1313 a_2700_6400.n29 a_2700_6400.n28 0.189974
R1314 a_2700_6400.n20 a_2700_6400.n13 0.1205
R1315 a_2700_6400.n24 a_2700_6400.n14 0.1205
R1316 a_2700_6400.n7 a_2700_6400.n0 0.1205
R1317 a_2700_6400.n11 a_2700_6400.n1 0.1205
R1318 a_2700_6400.n25 a_2700_6400.n13 0.0485
R1319 a_2700_6400.n25 a_2700_6400.n24 0.0485
R1320 a_2700_6400.n12 a_2700_6400.n0 0.0485
R1321 a_2700_6400.n12 a_2700_6400.n11 0.0485
R1322 a_14220_41600.n46 a_14220_41600.t31 113.632
R1323 a_14220_41600.n56 a_14220_41600.t16 113.632
R1324 a_14220_41600.n17 a_14220_41600.t47 113.632
R1325 a_14220_41600.n27 a_14220_41600.t32 113.632
R1326 a_14220_41600.n65 a_14220_41600.t23 109.174
R1327 a_14220_41600.n66 a_14220_41600.t24 109.174
R1328 a_14220_41600.n47 a_14220_41600.t30 109.174
R1329 a_14220_41600.n48 a_14220_41600.t29 109.174
R1330 a_14220_41600.n49 a_14220_41600.t28 109.174
R1331 a_14220_41600.n50 a_14220_41600.t27 109.174
R1332 a_14220_41600.n51 a_14220_41600.t26 109.174
R1333 a_14220_41600.n52 a_14220_41600.t25 109.174
R1334 a_14220_41600.n64 a_14220_41600.t22 109.174
R1335 a_14220_41600.n53 a_14220_41600.t21 109.174
R1336 a_14220_41600.n60 a_14220_41600.t20 109.174
R1337 a_14220_41600.n59 a_14220_41600.t19 109.174
R1338 a_14220_41600.n58 a_14220_41600.t18 109.174
R1339 a_14220_41600.n55 a_14220_41600.t17 109.174
R1340 a_14220_41600.n36 a_14220_41600.t39 109.174
R1341 a_14220_41600.n37 a_14220_41600.t40 109.174
R1342 a_14220_41600.n18 a_14220_41600.t46 109.174
R1343 a_14220_41600.n19 a_14220_41600.t45 109.174
R1344 a_14220_41600.n20 a_14220_41600.t44 109.174
R1345 a_14220_41600.n21 a_14220_41600.t43 109.174
R1346 a_14220_41600.n22 a_14220_41600.t42 109.174
R1347 a_14220_41600.n23 a_14220_41600.t41 109.174
R1348 a_14220_41600.n35 a_14220_41600.t38 109.174
R1349 a_14220_41600.n24 a_14220_41600.t37 109.174
R1350 a_14220_41600.n31 a_14220_41600.t36 109.174
R1351 a_14220_41600.n30 a_14220_41600.t35 109.174
R1352 a_14220_41600.n29 a_14220_41600.t34 109.174
R1353 a_14220_41600.n26 a_14220_41600.t33 109.174
R1354 a_14220_41600.n65 a_14220_41600.n40 18.4942
R1355 a_14220_41600.n67 a_14220_41600.n66 18.4942
R1356 a_14220_41600.n48 a_14220_41600.n45 18.4942
R1357 a_14220_41600.n49 a_14220_41600.n44 18.4942
R1358 a_14220_41600.n50 a_14220_41600.n43 18.4942
R1359 a_14220_41600.n51 a_14220_41600.n42 18.4942
R1360 a_14220_41600.n52 a_14220_41600.n41 18.4942
R1361 a_14220_41600.n64 a_14220_41600.n63 18.4942
R1362 a_14220_41600.n62 a_14220_41600.n53 18.4942
R1363 a_14220_41600.n61 a_14220_41600.n60 18.4942
R1364 a_14220_41600.n59 a_14220_41600.n54 18.4942
R1365 a_14220_41600.n58 a_14220_41600.n57 18.4942
R1366 a_14220_41600.n36 a_14220_41600.n11 18.4942
R1367 a_14220_41600.n38 a_14220_41600.n37 18.4942
R1368 a_14220_41600.n19 a_14220_41600.n16 18.4942
R1369 a_14220_41600.n20 a_14220_41600.n15 18.4942
R1370 a_14220_41600.n21 a_14220_41600.n14 18.4942
R1371 a_14220_41600.n22 a_14220_41600.n13 18.4942
R1372 a_14220_41600.n23 a_14220_41600.n12 18.4942
R1373 a_14220_41600.n35 a_14220_41600.n34 18.4942
R1374 a_14220_41600.n33 a_14220_41600.n24 18.4942
R1375 a_14220_41600.n32 a_14220_41600.n31 18.4942
R1376 a_14220_41600.n30 a_14220_41600.n25 18.4942
R1377 a_14220_41600.n29 a_14220_41600.n28 18.4942
R1378 a_14220_41600.n70 a_14220_41600.n69 14.1358
R1379 a_14220_41600.n65 a_14220_41600.n64 11.6805
R1380 a_14220_41600.n66 a_14220_41600.n65 11.6805
R1381 a_14220_41600.n48 a_14220_41600.n47 11.6805
R1382 a_14220_41600.n49 a_14220_41600.n48 11.6805
R1383 a_14220_41600.n50 a_14220_41600.n49 11.6805
R1384 a_14220_41600.n51 a_14220_41600.n50 11.6805
R1385 a_14220_41600.n52 a_14220_41600.n51 11.6805
R1386 a_14220_41600.n66 a_14220_41600.n52 11.6805
R1387 a_14220_41600.n64 a_14220_41600.n53 11.6805
R1388 a_14220_41600.n60 a_14220_41600.n53 11.6805
R1389 a_14220_41600.n60 a_14220_41600.n59 11.6805
R1390 a_14220_41600.n59 a_14220_41600.n58 11.6805
R1391 a_14220_41600.n58 a_14220_41600.n55 11.6805
R1392 a_14220_41600.n36 a_14220_41600.n35 11.6805
R1393 a_14220_41600.n37 a_14220_41600.n36 11.6805
R1394 a_14220_41600.n19 a_14220_41600.n18 11.6805
R1395 a_14220_41600.n20 a_14220_41600.n19 11.6805
R1396 a_14220_41600.n21 a_14220_41600.n20 11.6805
R1397 a_14220_41600.n22 a_14220_41600.n21 11.6805
R1398 a_14220_41600.n23 a_14220_41600.n22 11.6805
R1399 a_14220_41600.n37 a_14220_41600.n23 11.6805
R1400 a_14220_41600.n35 a_14220_41600.n24 11.6805
R1401 a_14220_41600.n31 a_14220_41600.n24 11.6805
R1402 a_14220_41600.n31 a_14220_41600.n30 11.6805
R1403 a_14220_41600.n30 a_14220_41600.n29 11.6805
R1404 a_14220_41600.n29 a_14220_41600.n26 11.6805
R1405 a_14220_41600.n69 a_14220_41600.n39 10.688
R1406 a_14220_41600.n69 a_14220_41600.n68 9.24157
R1407 a_14220_41600.n57 a_14220_41600.n56 7.17687
R1408 a_14220_41600.n46 a_14220_41600.n45 7.17687
R1409 a_14220_41600.n28 a_14220_41600.n27 7.17687
R1410 a_14220_41600.n17 a_14220_41600.n16 7.17687
R1411 a_14220_41600.n70 a_14220_41600.n10 6.5392
R1412 a_14220_41600.n1 a_14220_41600.t5 5.7796
R1413 a_14220_41600.n5 a_14220_41600.t9 5.73764
R1414 a_14220_41600.n71 a_14220_41600.t10 5.59012
R1415 a_14220_41600.n10 a_14220_41600.t8 5.54817
R1416 a_14220_41600.n73 a_14220_41600.n72 5.38537
R1417 a_14220_41600.n1 a_14220_41600.n0 5.38537
R1418 a_14220_41600.n3 a_14220_41600.n2 5.38537
R1419 a_14220_41600.n5 a_14220_41600.n4 5.32067
R1420 a_14220_41600.n7 a_14220_41600.n6 5.32067
R1421 a_14220_41600.n9 a_14220_41600.n8 5.32067
R1422 a_14220_41600.n71 a_14220_41600.n70 4.61063
R1423 a_14220_41600.n47 a_14220_41600.n46 4.42851
R1424 a_14220_41600.n56 a_14220_41600.n55 4.42851
R1425 a_14220_41600.n18 a_14220_41600.n17 4.42851
R1426 a_14220_41600.n27 a_14220_41600.n26 4.42851
R1427 a_14220_41600.n4 a_14220_41600.t14 0.228
R1428 a_14220_41600.n4 a_14220_41600.t3 0.228
R1429 a_14220_41600.n6 a_14220_41600.t11 0.228
R1430 a_14220_41600.n6 a_14220_41600.t15 0.228
R1431 a_14220_41600.n8 a_14220_41600.t7 0.228
R1432 a_14220_41600.n8 a_14220_41600.t12 0.228
R1433 a_14220_41600.n73 a_14220_41600.t13 0.20525
R1434 a_14220_41600.t0 a_14220_41600.n73 0.20525
R1435 a_14220_41600.n0 a_14220_41600.t4 0.20525
R1436 a_14220_41600.n0 a_14220_41600.t2 0.20525
R1437 a_14220_41600.n2 a_14220_41600.t6 0.20525
R1438 a_14220_41600.n2 a_14220_41600.t1 0.20525
R1439 a_14220_41600.n72 a_14220_41600.n71 0.189974
R1440 a_14220_41600.n72 a_14220_41600.n3 0.189974
R1441 a_14220_41600.n3 a_14220_41600.n1 0.189974
R1442 a_14220_41600.n10 a_14220_41600.n9 0.189974
R1443 a_14220_41600.n9 a_14220_41600.n7 0.189974
R1444 a_14220_41600.n7 a_14220_41600.n5 0.189974
R1445 a_14220_41600.n63 a_14220_41600.n40 0.1205
R1446 a_14220_41600.n63 a_14220_41600.n62 0.1205
R1447 a_14220_41600.n62 a_14220_41600.n61 0.1205
R1448 a_14220_41600.n61 a_14220_41600.n54 0.1205
R1449 a_14220_41600.n57 a_14220_41600.n54 0.1205
R1450 a_14220_41600.n45 a_14220_41600.n44 0.1205
R1451 a_14220_41600.n44 a_14220_41600.n43 0.1205
R1452 a_14220_41600.n43 a_14220_41600.n42 0.1205
R1453 a_14220_41600.n42 a_14220_41600.n41 0.1205
R1454 a_14220_41600.n67 a_14220_41600.n41 0.1205
R1455 a_14220_41600.n34 a_14220_41600.n11 0.1205
R1456 a_14220_41600.n34 a_14220_41600.n33 0.1205
R1457 a_14220_41600.n33 a_14220_41600.n32 0.1205
R1458 a_14220_41600.n32 a_14220_41600.n25 0.1205
R1459 a_14220_41600.n28 a_14220_41600.n25 0.1205
R1460 a_14220_41600.n16 a_14220_41600.n15 0.1205
R1461 a_14220_41600.n15 a_14220_41600.n14 0.1205
R1462 a_14220_41600.n14 a_14220_41600.n13 0.1205
R1463 a_14220_41600.n13 a_14220_41600.n12 0.1205
R1464 a_14220_41600.n38 a_14220_41600.n12 0.1205
R1465 a_14220_41600.n68 a_14220_41600.n40 0.0485
R1466 a_14220_41600.n68 a_14220_41600.n67 0.0485
R1467 a_14220_41600.n39 a_14220_41600.n11 0.0485
R1468 a_14220_41600.n39 a_14220_41600.n38 0.0485
R1469 a_6924_41600.n15 a_6924_41600.t11 113.632
R1470 a_6924_41600.n19 a_6924_41600.t4 113.632
R1471 a_6924_41600.n2 a_6924_41600.t19 113.632
R1472 a_6924_41600.n6 a_6924_41600.t12 113.632
R1473 a_6924_41600.n22 a_6924_41600.t7 109.174
R1474 a_6924_41600.n23 a_6924_41600.t8 109.174
R1475 a_6924_41600.n16 a_6924_41600.t10 109.174
R1476 a_6924_41600.n17 a_6924_41600.t9 109.174
R1477 a_6924_41600.n21 a_6924_41600.t6 109.174
R1478 a_6924_41600.n18 a_6924_41600.t5 109.174
R1479 a_6924_41600.n9 a_6924_41600.t15 109.174
R1480 a_6924_41600.n10 a_6924_41600.t16 109.174
R1481 a_6924_41600.n3 a_6924_41600.t18 109.174
R1482 a_6924_41600.n4 a_6924_41600.t17 109.174
R1483 a_6924_41600.n8 a_6924_41600.t14 109.174
R1484 a_6924_41600.n5 a_6924_41600.t13 109.174
R1485 a_6924_41600.n22 a_6924_41600.n13 18.4942
R1486 a_6924_41600.n24 a_6924_41600.n23 18.4942
R1487 a_6924_41600.n17 a_6924_41600.n14 18.4942
R1488 a_6924_41600.n21 a_6924_41600.n20 18.4942
R1489 a_6924_41600.n9 a_6924_41600.n0 18.4942
R1490 a_6924_41600.n11 a_6924_41600.n10 18.4942
R1491 a_6924_41600.n4 a_6924_41600.n1 18.4942
R1492 a_6924_41600.n8 a_6924_41600.n7 18.4942
R1493 a_6924_41600.n28 a_6924_41600.n26 17.2799
R1494 a_6924_41600.n22 a_6924_41600.n21 11.6805
R1495 a_6924_41600.n23 a_6924_41600.n22 11.6805
R1496 a_6924_41600.n17 a_6924_41600.n16 11.6805
R1497 a_6924_41600.n23 a_6924_41600.n17 11.6805
R1498 a_6924_41600.n21 a_6924_41600.n18 11.6805
R1499 a_6924_41600.n9 a_6924_41600.n8 11.6805
R1500 a_6924_41600.n10 a_6924_41600.n9 11.6805
R1501 a_6924_41600.n4 a_6924_41600.n3 11.6805
R1502 a_6924_41600.n10 a_6924_41600.n4 11.6805
R1503 a_6924_41600.n8 a_6924_41600.n5 11.6805
R1504 a_6924_41600.n26 a_6924_41600.n12 10.013
R1505 a_6924_41600.n26 a_6924_41600.n25 9.91657
R1506 a_6924_41600.n20 a_6924_41600.n19 7.17687
R1507 a_6924_41600.n15 a_6924_41600.n14 7.17687
R1508 a_6924_41600.n7 a_6924_41600.n6 7.17687
R1509 a_6924_41600.n2 a_6924_41600.n1 7.17687
R1510 a_6924_41600.n29 a_6924_41600.n28 6.5392
R1511 a_6924_41600.n27 a_6924_41600.t3 5.7796
R1512 a_6924_41600.t1 a_6924_41600.n29 5.73764
R1513 a_6924_41600.n27 a_6924_41600.t2 5.59012
R1514 a_6924_41600.n29 a_6924_41600.t0 5.54817
R1515 a_6924_41600.n28 a_6924_41600.n27 4.61063
R1516 a_6924_41600.n16 a_6924_41600.n15 4.42851
R1517 a_6924_41600.n19 a_6924_41600.n18 4.42851
R1518 a_6924_41600.n3 a_6924_41600.n2 4.42851
R1519 a_6924_41600.n6 a_6924_41600.n5 4.42851
R1520 a_6924_41600.n20 a_6924_41600.n13 0.1205
R1521 a_6924_41600.n24 a_6924_41600.n14 0.1205
R1522 a_6924_41600.n7 a_6924_41600.n0 0.1205
R1523 a_6924_41600.n11 a_6924_41600.n1 0.1205
R1524 a_6924_41600.n25 a_6924_41600.n13 0.0485
R1525 a_6924_41600.n25 a_6924_41600.n24 0.0485
R1526 a_6924_41600.n12 a_6924_41600.n0 0.0485
R1527 a_6924_41600.n12 a_6924_41600.n11 0.0485
R1528 a_4812_41600.n15 a_4812_41600.t15 113.632
R1529 a_4812_41600.n19 a_4812_41600.t8 113.632
R1530 a_4812_41600.n2 a_4812_41600.t23 113.632
R1531 a_4812_41600.n6 a_4812_41600.t16 113.632
R1532 a_4812_41600.n22 a_4812_41600.t11 109.174
R1533 a_4812_41600.n23 a_4812_41600.t12 109.174
R1534 a_4812_41600.n16 a_4812_41600.t14 109.174
R1535 a_4812_41600.n17 a_4812_41600.t13 109.174
R1536 a_4812_41600.n21 a_4812_41600.t10 109.174
R1537 a_4812_41600.n18 a_4812_41600.t9 109.174
R1538 a_4812_41600.n9 a_4812_41600.t19 109.174
R1539 a_4812_41600.n10 a_4812_41600.t20 109.174
R1540 a_4812_41600.n3 a_4812_41600.t22 109.174
R1541 a_4812_41600.n4 a_4812_41600.t21 109.174
R1542 a_4812_41600.n8 a_4812_41600.t18 109.174
R1543 a_4812_41600.n5 a_4812_41600.t17 109.174
R1544 a_4812_41600.n22 a_4812_41600.n13 18.4942
R1545 a_4812_41600.n24 a_4812_41600.n23 18.4942
R1546 a_4812_41600.n17 a_4812_41600.n14 18.4942
R1547 a_4812_41600.n21 a_4812_41600.n20 18.4942
R1548 a_4812_41600.n9 a_4812_41600.n0 18.4942
R1549 a_4812_41600.n11 a_4812_41600.n10 18.4942
R1550 a_4812_41600.n4 a_4812_41600.n1 18.4942
R1551 a_4812_41600.n8 a_4812_41600.n7 18.4942
R1552 a_4812_41600.n30 a_4812_41600.n26 16.9914
R1553 a_4812_41600.n22 a_4812_41600.n21 11.6805
R1554 a_4812_41600.n23 a_4812_41600.n22 11.6805
R1555 a_4812_41600.n17 a_4812_41600.n16 11.6805
R1556 a_4812_41600.n23 a_4812_41600.n17 11.6805
R1557 a_4812_41600.n21 a_4812_41600.n18 11.6805
R1558 a_4812_41600.n9 a_4812_41600.n8 11.6805
R1559 a_4812_41600.n10 a_4812_41600.n9 11.6805
R1560 a_4812_41600.n4 a_4812_41600.n3 11.6805
R1561 a_4812_41600.n10 a_4812_41600.n4 11.6805
R1562 a_4812_41600.n8 a_4812_41600.n5 11.6805
R1563 a_4812_41600.n26 a_4812_41600.n12 10.3505
R1564 a_4812_41600.n26 a_4812_41600.n25 9.57907
R1565 a_4812_41600.n20 a_4812_41600.n19 7.17687
R1566 a_4812_41600.n15 a_4812_41600.n14 7.17687
R1567 a_4812_41600.n7 a_4812_41600.n6 7.17687
R1568 a_4812_41600.n2 a_4812_41600.n1 7.17687
R1569 a_4812_41600.n31 a_4812_41600.n30 6.5392
R1570 a_4812_41600.n28 a_4812_41600.t7 5.7796
R1571 a_4812_41600.t3 a_4812_41600.n33 5.73764
R1572 a_4812_41600.n29 a_4812_41600.t4 5.59012
R1573 a_4812_41600.n31 a_4812_41600.t0 5.54817
R1574 a_4812_41600.n28 a_4812_41600.n27 5.38537
R1575 a_4812_41600.n33 a_4812_41600.n32 5.32067
R1576 a_4812_41600.n30 a_4812_41600.n29 4.61063
R1577 a_4812_41600.n16 a_4812_41600.n15 4.42851
R1578 a_4812_41600.n19 a_4812_41600.n18 4.42851
R1579 a_4812_41600.n3 a_4812_41600.n2 4.42851
R1580 a_4812_41600.n6 a_4812_41600.n5 4.42851
R1581 a_4812_41600.n32 a_4812_41600.t1 0.228
R1582 a_4812_41600.n32 a_4812_41600.t2 0.228
R1583 a_4812_41600.n27 a_4812_41600.t5 0.20525
R1584 a_4812_41600.n27 a_4812_41600.t6 0.20525
R1585 a_4812_41600.n33 a_4812_41600.n31 0.189974
R1586 a_4812_41600.n29 a_4812_41600.n28 0.189974
R1587 a_4812_41600.n20 a_4812_41600.n13 0.1205
R1588 a_4812_41600.n24 a_4812_41600.n14 0.1205
R1589 a_4812_41600.n7 a_4812_41600.n0 0.1205
R1590 a_4812_41600.n11 a_4812_41600.n1 0.1205
R1591 a_4812_41600.n25 a_4812_41600.n13 0.0485
R1592 a_4812_41600.n25 a_4812_41600.n24 0.0485
R1593 a_4812_41600.n12 a_4812_41600.n0 0.0485
R1594 a_4812_41600.n12 a_4812_41600.n11 0.0485
R1595 a_2700_41600.n15 a_2700_41600.t15 113.632
R1596 a_2700_41600.n19 a_2700_41600.t8 113.632
R1597 a_2700_41600.n2 a_2700_41600.t23 113.632
R1598 a_2700_41600.n6 a_2700_41600.t16 113.632
R1599 a_2700_41600.n22 a_2700_41600.t11 109.174
R1600 a_2700_41600.n23 a_2700_41600.t12 109.174
R1601 a_2700_41600.n16 a_2700_41600.t14 109.174
R1602 a_2700_41600.n17 a_2700_41600.t13 109.174
R1603 a_2700_41600.n21 a_2700_41600.t10 109.174
R1604 a_2700_41600.n18 a_2700_41600.t9 109.174
R1605 a_2700_41600.n9 a_2700_41600.t19 109.174
R1606 a_2700_41600.n10 a_2700_41600.t20 109.174
R1607 a_2700_41600.n3 a_2700_41600.t22 109.174
R1608 a_2700_41600.n4 a_2700_41600.t21 109.174
R1609 a_2700_41600.n8 a_2700_41600.t18 109.174
R1610 a_2700_41600.n5 a_2700_41600.t17 109.174
R1611 a_2700_41600.n22 a_2700_41600.n13 18.4942
R1612 a_2700_41600.n24 a_2700_41600.n23 18.4942
R1613 a_2700_41600.n17 a_2700_41600.n14 18.4942
R1614 a_2700_41600.n21 a_2700_41600.n20 18.4942
R1615 a_2700_41600.n9 a_2700_41600.n0 18.4942
R1616 a_2700_41600.n11 a_2700_41600.n10 18.4942
R1617 a_2700_41600.n4 a_2700_41600.n1 18.4942
R1618 a_2700_41600.n8 a_2700_41600.n7 18.4942
R1619 a_2700_41600.n30 a_2700_41600.n26 16.7028
R1620 a_2700_41600.n22 a_2700_41600.n21 11.6805
R1621 a_2700_41600.n23 a_2700_41600.n22 11.6805
R1622 a_2700_41600.n17 a_2700_41600.n16 11.6805
R1623 a_2700_41600.n23 a_2700_41600.n17 11.6805
R1624 a_2700_41600.n21 a_2700_41600.n18 11.6805
R1625 a_2700_41600.n9 a_2700_41600.n8 11.6805
R1626 a_2700_41600.n10 a_2700_41600.n9 11.6805
R1627 a_2700_41600.n4 a_2700_41600.n3 11.6805
R1628 a_2700_41600.n10 a_2700_41600.n4 11.6805
R1629 a_2700_41600.n8 a_2700_41600.n5 11.6805
R1630 a_2700_41600.n26 a_2700_41600.n12 10.688
R1631 a_2700_41600.n26 a_2700_41600.n25 9.24157
R1632 a_2700_41600.n20 a_2700_41600.n19 7.17687
R1633 a_2700_41600.n15 a_2700_41600.n14 7.17687
R1634 a_2700_41600.n7 a_2700_41600.n6 7.17687
R1635 a_2700_41600.n2 a_2700_41600.n1 7.17687
R1636 a_2700_41600.n31 a_2700_41600.n30 6.5392
R1637 a_2700_41600.n28 a_2700_41600.t7 5.7796
R1638 a_2700_41600.t3 a_2700_41600.n33 5.73764
R1639 a_2700_41600.n29 a_2700_41600.t4 5.59012
R1640 a_2700_41600.n31 a_2700_41600.t0 5.54817
R1641 a_2700_41600.n28 a_2700_41600.n27 5.38537
R1642 a_2700_41600.n33 a_2700_41600.n32 5.32067
R1643 a_2700_41600.n30 a_2700_41600.n29 4.61063
R1644 a_2700_41600.n16 a_2700_41600.n15 4.42851
R1645 a_2700_41600.n19 a_2700_41600.n18 4.42851
R1646 a_2700_41600.n3 a_2700_41600.n2 4.42851
R1647 a_2700_41600.n6 a_2700_41600.n5 4.42851
R1648 a_2700_41600.n32 a_2700_41600.t1 0.228
R1649 a_2700_41600.n32 a_2700_41600.t2 0.228
R1650 a_2700_41600.n27 a_2700_41600.t5 0.20525
R1651 a_2700_41600.n27 a_2700_41600.t6 0.20525
R1652 a_2700_41600.n33 a_2700_41600.n31 0.189974
R1653 a_2700_41600.n29 a_2700_41600.n28 0.189974
R1654 a_2700_41600.n20 a_2700_41600.n13 0.1205
R1655 a_2700_41600.n24 a_2700_41600.n14 0.1205
R1656 a_2700_41600.n7 a_2700_41600.n0 0.1205
R1657 a_2700_41600.n11 a_2700_41600.n1 0.1205
R1658 a_2700_41600.n25 a_2700_41600.n13 0.0485
R1659 a_2700_41600.n25 a_2700_41600.n24 0.0485
R1660 a_2700_41600.n12 a_2700_41600.n0 0.0485
R1661 a_2700_41600.n12 a_2700_41600.n11 0.0485
C0 VDD O_SENSE 21.1169f
C1 CLKP_H VDD 2.64315f
C2 VDD O_CAPTURE_CLK 11.2502f
C3 CLKN_H CLKN_HB 0.13381f
C4 O_CAPTURE_CLKB VDD 11.308f
C5 O_CAPTURE_CLKB O_CAPTURE_CLK 0.13895f
C6 CLKN_H VDD 2.64315f
C7 VDD CLKN_HB 2.39456f
C8 VDD E_SENSE 21.1169f
C9 CLKP_HB E_CAPTURE_CLKB 0.05079f
C10 O_CAPTURE_CLKB CLKN_HB 0.05079f
C11 CLKP_HB VDD 2.39456f
C12 E_CAPTURE_CLKB E_CAPTURE_CLK 0.13895f
C13 VDD E_CAPTURE_CLK 11.2502f
C14 VDD E_CAPTURE_CLKB 11.308f
C15 CLKP_HB CLKP_H 0.13381f
C16 E_SENSE VSS 24.17468f
C17 E_CAPTURE_CLK VSS 13.22096f
C18 E_CAPTURE_CLKB VSS 11.51361f
C19 CLKP_H VSS 8.80759f
C20 CLKP_HB VSS 9.47044f
C21 O_SENSE VSS 24.17468f
C22 O_CAPTURE_CLK VSS 13.22096f
C23 O_CAPTURE_CLKB VSS 11.51361f
C24 CLKN_H VSS 8.80759f
C25 CLKN_HB VSS 9.93834f
C26 VDD VSS 2.11459p
C27 a_2700_41600.n0 VSS 0.0537f
C28 a_2700_41600.n1 VSS 0.18551f
C29 a_2700_41600.n2 VSS 0.0917f
C30 a_2700_41600.n3 VSS 0.09829f
C31 a_2700_41600.n4 VSS 0.09829f
C32 a_2700_41600.n5 VSS 0.09829f
C33 a_2700_41600.n6 VSS 0.0917f
C34 a_2700_41600.n7 VSS 0.18551f
C35 a_2700_41600.n8 VSS 0.09829f
C36 a_2700_41600.n9 VSS 0.09829f
C37 a_2700_41600.n10 VSS 0.09829f
C38 a_2700_41600.n11 VSS 0.0537f
C39 a_2700_41600.n12 VSS 0.30147f
C40 a_2700_41600.n13 VSS 0.0537f
C41 a_2700_41600.n14 VSS 0.18551f
C42 a_2700_41600.n15 VSS 0.0917f
C43 a_2700_41600.n16 VSS 0.09829f
C44 a_2700_41600.n17 VSS 0.09829f
C45 a_2700_41600.n18 VSS 0.09829f
C46 a_2700_41600.n19 VSS 0.0917f
C47 a_2700_41600.n20 VSS 0.18551f
C48 a_2700_41600.n21 VSS 0.09829f
C49 a_2700_41600.n22 VSS 0.09829f
C50 a_2700_41600.n23 VSS 0.09829f
C51 a_2700_41600.n24 VSS 0.0537f
C52 a_2700_41600.n25 VSS 0.2258f
C53 a_2700_41600.n26 VSS 1.98338f
C54 a_2700_41600.t7 VSS 0.78584f
C55 a_2700_41600.t6 VSS 0.18218f
C56 a_2700_41600.t5 VSS 0.18218f
C57 a_2700_41600.n27 VSS 0.57664f
C58 a_2700_41600.n28 VSS 0.32498f
C59 a_2700_41600.t4 VSS 0.78062f
C60 a_2700_41600.n29 VSS 0.23385f
C61 a_2700_41600.n30 VSS 1.84385f
C62 a_2700_41600.t0 VSS 0.78201f
C63 a_2700_41600.n31 VSS 0.34487f
C64 a_2700_41600.t2 VSS 0.18218f
C65 a_2700_41600.t1 VSS 0.18218f
C66 a_2700_41600.n32 VSS 0.58092f
C67 a_2700_41600.n33 VSS 0.31931f
C68 a_2700_41600.t3 VSS 0.78723f
C69 a_4812_41600.n0 VSS 0.05591f
C70 a_4812_41600.n1 VSS 0.19315f
C71 a_4812_41600.n2 VSS 0.09547f
C72 a_4812_41600.n3 VSS 0.10233f
C73 a_4812_41600.n4 VSS 0.10233f
C74 a_4812_41600.n5 VSS 0.10233f
C75 a_4812_41600.n6 VSS 0.09547f
C76 a_4812_41600.n7 VSS 0.19315f
C77 a_4812_41600.n8 VSS 0.10233f
C78 a_4812_41600.n9 VSS 0.10233f
C79 a_4812_41600.n10 VSS 0.10233f
C80 a_4812_41600.n11 VSS 0.05591f
C81 a_4812_41600.n12 VSS 0.29039f
C82 a_4812_41600.n13 VSS 0.05591f
C83 a_4812_41600.n14 VSS 0.19315f
C84 a_4812_41600.n15 VSS 0.09547f
C85 a_4812_41600.n16 VSS 0.10233f
C86 a_4812_41600.n17 VSS 0.10233f
C87 a_4812_41600.n18 VSS 0.10233f
C88 a_4812_41600.n19 VSS 0.09547f
C89 a_4812_41600.n20 VSS 0.19315f
C90 a_4812_41600.n21 VSS 0.10233f
C91 a_4812_41600.n22 VSS 0.10233f
C92 a_4812_41600.n23 VSS 0.10233f
C93 a_4812_41600.n24 VSS 0.05591f
C94 a_4812_41600.n25 VSS 0.24795f
C95 a_4812_41600.n26 VSS 2.13538f
C96 a_4812_41600.t7 VSS 0.80428f
C97 a_4812_41600.t6 VSS 0.17604f
C98 a_4812_41600.t5 VSS 0.17604f
C99 a_4812_41600.n27 VSS 0.60036f
C100 a_4812_41600.n28 VSS 0.33836f
C101 a_4812_41600.t4 VSS 0.79885f
C102 a_4812_41600.n29 VSS 0.24347f
C103 a_4812_41600.n30 VSS 1.89322f
C104 a_4812_41600.t0 VSS 0.8003f
C105 a_4812_41600.n31 VSS 0.35906f
C106 a_4812_41600.t2 VSS 0.17604f
C107 a_4812_41600.t1 VSS 0.17604f
C108 a_4812_41600.n32 VSS 0.60482f
C109 a_4812_41600.n33 VSS 0.33245f
C110 a_4812_41600.t3 VSS 0.80572f
C111 a_6924_41600.n0 VSS 0.05123f
C112 a_6924_41600.n1 VSS 0.17698f
C113 a_6924_41600.n2 VSS 0.08748f
C114 a_6924_41600.n3 VSS 0.09377f
C115 a_6924_41600.n4 VSS 0.09377f
C116 a_6924_41600.n5 VSS 0.09377f
C117 a_6924_41600.n6 VSS 0.08748f
C118 a_6924_41600.n7 VSS 0.17698f
C119 a_6924_41600.n8 VSS 0.09377f
C120 a_6924_41600.n9 VSS 0.09377f
C121 a_6924_41600.n10 VSS 0.09377f
C122 a_6924_41600.n11 VSS 0.05123f
C123 a_6924_41600.n12 VSS 0.24719f
C124 a_6924_41600.n13 VSS 0.05123f
C125 a_6924_41600.n14 VSS 0.17698f
C126 a_6924_41600.n15 VSS 0.08748f
C127 a_6924_41600.n16 VSS 0.09377f
C128 a_6924_41600.n17 VSS 0.09377f
C129 a_6924_41600.n18 VSS 0.09377f
C130 a_6924_41600.n19 VSS 0.08748f
C131 a_6924_41600.n20 VSS 0.17698f
C132 a_6924_41600.n21 VSS 0.09377f
C133 a_6924_41600.n22 VSS 0.09377f
C134 a_6924_41600.n23 VSS 0.09377f
C135 a_6924_41600.n24 VSS 0.05123f
C136 a_6924_41600.n25 VSS 0.24231f
C137 a_6924_41600.n26 VSS 2.01533f
C138 a_6924_41600.t3 VSS 0.75297f
C139 a_6924_41600.t2 VSS 0.748f
C140 a_6924_41600.n27 VSS 0.37002f
C141 a_6924_41600.n28 VSS 1.71038f
C142 a_6924_41600.t0 VSS 0.74932f
C143 a_6924_41600.n29 VSS 0.47462f
C144 a_6924_41600.t1 VSS 0.7543f
C145 a_14220_41600.t13 VSS 0.20207f
C146 a_14220_41600.t5 VSS 0.79986f
C147 a_14220_41600.t2 VSS 0.20207f
C148 a_14220_41600.t4 VSS 0.20207f
C149 a_14220_41600.n0 VSS 0.57063f
C150 a_14220_41600.n1 VSS 0.3216f
C151 a_14220_41600.t1 VSS 0.20207f
C152 a_14220_41600.t6 VSS 0.20207f
C153 a_14220_41600.n2 VSS 0.57063f
C154 a_14220_41600.n3 VSS 0.16919f
C155 a_14220_41600.t9 VSS 0.80123f
C156 a_14220_41600.t3 VSS 0.20207f
C157 a_14220_41600.t14 VSS 0.20207f
C158 a_14220_41600.n4 VSS 0.57487f
C159 a_14220_41600.n5 VSS 0.31599f
C160 a_14220_41600.t15 VSS 0.20207f
C161 a_14220_41600.t11 VSS 0.20207f
C162 a_14220_41600.n6 VSS 0.57487f
C163 a_14220_41600.n7 VSS 0.16495f
C164 a_14220_41600.t12 VSS 0.20207f
C165 a_14220_41600.t7 VSS 0.20207f
C166 a_14220_41600.n8 VSS 0.57487f
C167 a_14220_41600.n9 VSS 0.16495f
C168 a_14220_41600.t8 VSS 0.79608f
C169 a_14220_41600.n10 VSS 0.34128f
C170 a_14220_41600.n11 VSS 0.05314f
C171 a_14220_41600.n12 VSS 0.06307f
C172 a_14220_41600.n13 VSS 0.06307f
C173 a_14220_41600.n14 VSS 0.06307f
C174 a_14220_41600.n15 VSS 0.06307f
C175 a_14220_41600.n16 VSS 0.18358f
C176 a_14220_41600.n17 VSS 0.09074f
C177 a_14220_41600.n18 VSS 0.09727f
C178 a_14220_41600.n19 VSS 0.09727f
C179 a_14220_41600.n20 VSS 0.09727f
C180 a_14220_41600.n21 VSS 0.09727f
C181 a_14220_41600.n22 VSS 0.09727f
C182 a_14220_41600.n23 VSS 0.09727f
C183 a_14220_41600.n24 VSS 0.09727f
C184 a_14220_41600.n25 VSS 0.06307f
C185 a_14220_41600.n26 VSS 0.09727f
C186 a_14220_41600.n27 VSS 0.09074f
C187 a_14220_41600.n28 VSS 0.18358f
C188 a_14220_41600.n29 VSS 0.09727f
C189 a_14220_41600.n30 VSS 0.09727f
C190 a_14220_41600.n31 VSS 0.09727f
C191 a_14220_41600.n32 VSS 0.06307f
C192 a_14220_41600.n33 VSS 0.06307f
C193 a_14220_41600.n34 VSS 0.06307f
C194 a_14220_41600.n35 VSS 0.09727f
C195 a_14220_41600.n36 VSS 0.09727f
C196 a_14220_41600.n37 VSS 0.09727f
C197 a_14220_41600.n38 VSS 0.05314f
C198 a_14220_41600.n39 VSS 0.51991f
C199 a_14220_41600.n40 VSS 0.05314f
C200 a_14220_41600.n41 VSS 0.06307f
C201 a_14220_41600.n42 VSS 0.06307f
C202 a_14220_41600.n43 VSS 0.06307f
C203 a_14220_41600.n44 VSS 0.06307f
C204 a_14220_41600.n45 VSS 0.18358f
C205 a_14220_41600.n46 VSS 0.09074f
C206 a_14220_41600.n47 VSS 0.09727f
C207 a_14220_41600.n48 VSS 0.09727f
C208 a_14220_41600.n49 VSS 0.09727f
C209 a_14220_41600.n50 VSS 0.09727f
C210 a_14220_41600.n51 VSS 0.09727f
C211 a_14220_41600.n52 VSS 0.09727f
C212 a_14220_41600.n53 VSS 0.09727f
C213 a_14220_41600.n54 VSS 0.06307f
C214 a_14220_41600.n55 VSS 0.09727f
C215 a_14220_41600.n56 VSS 0.09074f
C216 a_14220_41600.n57 VSS 0.18358f
C217 a_14220_41600.n58 VSS 0.09727f
C218 a_14220_41600.n59 VSS 0.09727f
C219 a_14220_41600.n60 VSS 0.09727f
C220 a_14220_41600.n61 VSS 0.06307f
C221 a_14220_41600.n62 VSS 0.06307f
C222 a_14220_41600.n63 VSS 0.06307f
C223 a_14220_41600.n64 VSS 0.09727f
C224 a_14220_41600.n65 VSS 0.09727f
C225 a_14220_41600.n66 VSS 0.09727f
C226 a_14220_41600.n67 VSS 0.05314f
C227 a_14220_41600.n68 VSS 0.4198f
C228 a_14220_41600.n69 VSS 1.97655f
C229 a_14220_41600.n70 VSS 1.51386f
C230 a_14220_41600.t10 VSS 0.7947f
C231 a_14220_41600.n71 VSS 0.23141f
C232 a_14220_41600.n72 VSS 0.16919f
C233 a_14220_41600.n73 VSS 0.57063f
C234 a_14220_41600.t0 VSS 0.20207f
C235 a_2700_6400.n0 VSS 0.0537f
C236 a_2700_6400.n1 VSS 0.18551f
C237 a_2700_6400.n2 VSS 0.0917f
C238 a_2700_6400.n3 VSS 0.09829f
C239 a_2700_6400.n4 VSS 0.09829f
C240 a_2700_6400.n5 VSS 0.09829f
C241 a_2700_6400.n6 VSS 0.0917f
C242 a_2700_6400.n7 VSS 0.18551f
C243 a_2700_6400.n8 VSS 0.09829f
C244 a_2700_6400.n9 VSS 0.09829f
C245 a_2700_6400.n10 VSS 0.09829f
C246 a_2700_6400.n11 VSS 0.0537f
C247 a_2700_6400.n12 VSS 0.30147f
C248 a_2700_6400.n13 VSS 0.0537f
C249 a_2700_6400.n14 VSS 0.18551f
C250 a_2700_6400.n15 VSS 0.0917f
C251 a_2700_6400.n16 VSS 0.09829f
C252 a_2700_6400.n17 VSS 0.09829f
C253 a_2700_6400.n18 VSS 0.09829f
C254 a_2700_6400.n19 VSS 0.0917f
C255 a_2700_6400.n20 VSS 0.18551f
C256 a_2700_6400.n21 VSS 0.09829f
C257 a_2700_6400.n22 VSS 0.09829f
C258 a_2700_6400.n23 VSS 0.09829f
C259 a_2700_6400.n24 VSS 0.0537f
C260 a_2700_6400.n25 VSS 0.2258f
C261 a_2700_6400.n26 VSS 1.98338f
C262 a_2700_6400.t7 VSS 0.78751f
C263 a_2700_6400.t6 VSS 0.18382f
C264 a_2700_6400.t5 VSS 0.18382f
C265 a_2700_6400.n27 VSS 0.57664f
C266 a_2700_6400.n28 VSS 0.32498f
C267 a_2700_6400.t4 VSS 0.78229f
C268 a_2700_6400.n29 VSS 0.23385f
C269 a_2700_6400.n30 VSS 1.84385f
C270 a_2700_6400.t0 VSS 0.78369f
C271 a_2700_6400.n31 VSS 0.34487f
C272 a_2700_6400.t2 VSS 0.18382f
C273 a_2700_6400.t1 VSS 0.18382f
C274 a_2700_6400.n32 VSS 0.58092f
C275 a_2700_6400.n33 VSS 0.31931f
C276 a_2700_6400.t3 VSS 0.7889f
C277 a_4812_6400.n0 VSS 0.05591f
C278 a_4812_6400.n1 VSS 0.19315f
C279 a_4812_6400.n2 VSS 0.09547f
C280 a_4812_6400.n3 VSS 0.10233f
C281 a_4812_6400.n4 VSS 0.10233f
C282 a_4812_6400.n5 VSS 0.10233f
C283 a_4812_6400.n6 VSS 0.09547f
C284 a_4812_6400.n7 VSS 0.19315f
C285 a_4812_6400.n8 VSS 0.10233f
C286 a_4812_6400.n9 VSS 0.10233f
C287 a_4812_6400.n10 VSS 0.10233f
C288 a_4812_6400.n11 VSS 0.05591f
C289 a_4812_6400.n12 VSS 0.29039f
C290 a_4812_6400.n13 VSS 0.05591f
C291 a_4812_6400.n14 VSS 0.19315f
C292 a_4812_6400.n15 VSS 0.09547f
C293 a_4812_6400.n16 VSS 0.10233f
C294 a_4812_6400.n17 VSS 0.10233f
C295 a_4812_6400.n18 VSS 0.10233f
C296 a_4812_6400.n19 VSS 0.09547f
C297 a_4812_6400.n20 VSS 0.19315f
C298 a_4812_6400.n21 VSS 0.10233f
C299 a_4812_6400.n22 VSS 0.10233f
C300 a_4812_6400.n23 VSS 0.10233f
C301 a_4812_6400.n24 VSS 0.05591f
C302 a_4812_6400.n25 VSS 0.24795f
C303 a_4812_6400.n26 VSS 2.13538f
C304 a_4812_6400.t7 VSS 0.80428f
C305 a_4812_6400.t6 VSS 0.17604f
C306 a_4812_6400.t5 VSS 0.17604f
C307 a_4812_6400.n27 VSS 0.60036f
C308 a_4812_6400.n28 VSS 0.33836f
C309 a_4812_6400.t4 VSS 0.79885f
C310 a_4812_6400.n29 VSS 0.24347f
C311 a_4812_6400.n30 VSS 1.89322f
C312 a_4812_6400.t0 VSS 0.8003f
C313 a_4812_6400.n31 VSS 0.35906f
C314 a_4812_6400.t2 VSS 0.17604f
C315 a_4812_6400.t1 VSS 0.17604f
C316 a_4812_6400.n32 VSS 0.60482f
C317 a_4812_6400.n33 VSS 0.33245f
C318 a_4812_6400.t3 VSS 0.80572f
C319 a_6924_6400.n0 VSS 0.05123f
C320 a_6924_6400.n1 VSS 0.17698f
C321 a_6924_6400.n2 VSS 0.08748f
C322 a_6924_6400.n3 VSS 0.09377f
C323 a_6924_6400.n4 VSS 0.09377f
C324 a_6924_6400.n5 VSS 0.09377f
C325 a_6924_6400.n6 VSS 0.08748f
C326 a_6924_6400.n7 VSS 0.17698f
C327 a_6924_6400.n8 VSS 0.09377f
C328 a_6924_6400.n9 VSS 0.09377f
C329 a_6924_6400.n10 VSS 0.09377f
C330 a_6924_6400.n11 VSS 0.05123f
C331 a_6924_6400.n12 VSS 0.24719f
C332 a_6924_6400.n13 VSS 0.05123f
C333 a_6924_6400.n14 VSS 0.17698f
C334 a_6924_6400.n15 VSS 0.08748f
C335 a_6924_6400.n16 VSS 0.09377f
C336 a_6924_6400.n17 VSS 0.09377f
C337 a_6924_6400.n18 VSS 0.09377f
C338 a_6924_6400.n19 VSS 0.08748f
C339 a_6924_6400.n20 VSS 0.17698f
C340 a_6924_6400.n21 VSS 0.09377f
C341 a_6924_6400.n22 VSS 0.09377f
C342 a_6924_6400.n23 VSS 0.09377f
C343 a_6924_6400.n24 VSS 0.05123f
C344 a_6924_6400.n25 VSS 0.24231f
C345 a_6924_6400.n26 VSS 2.01533f
C346 a_6924_6400.t3 VSS 0.75465f
C347 a_6924_6400.t2 VSS 0.74967f
C348 a_6924_6400.n27 VSS 0.37002f
C349 a_6924_6400.n28 VSS 1.71038f
C350 a_6924_6400.t0 VSS 0.751f
C351 a_6924_6400.n29 VSS 0.47462f
C352 a_6924_6400.t1 VSS 0.75597f
C353 a_14220_6400.t4 VSS 0.20207f
C354 a_14220_6400.t1 VSS 0.79986f
C355 a_14220_6400.t2 VSS 0.20207f
C356 a_14220_6400.t3 VSS 0.20207f
C357 a_14220_6400.n0 VSS 0.57063f
C358 a_14220_6400.n1 VSS 0.3216f
C359 a_14220_6400.t15 VSS 0.20207f
C360 a_14220_6400.t14 VSS 0.20207f
C361 a_14220_6400.n2 VSS 0.57063f
C362 a_14220_6400.n3 VSS 0.16919f
C363 a_14220_6400.t5 VSS 0.80123f
C364 a_14220_6400.t7 VSS 0.20207f
C365 a_14220_6400.t8 VSS 0.20207f
C366 a_14220_6400.n4 VSS 0.57487f
C367 a_14220_6400.n5 VSS 0.31599f
C368 a_14220_6400.t12 VSS 0.20207f
C369 a_14220_6400.t13 VSS 0.20207f
C370 a_14220_6400.n6 VSS 0.57487f
C371 a_14220_6400.n7 VSS 0.16495f
C372 a_14220_6400.t9 VSS 0.20207f
C373 a_14220_6400.t10 VSS 0.20207f
C374 a_14220_6400.n8 VSS 0.57487f
C375 a_14220_6400.n9 VSS 0.16495f
C376 a_14220_6400.t11 VSS 0.79608f
C377 a_14220_6400.n10 VSS 0.34128f
C378 a_14220_6400.n11 VSS 0.05314f
C379 a_14220_6400.n12 VSS 0.06307f
C380 a_14220_6400.n13 VSS 0.06307f
C381 a_14220_6400.n14 VSS 0.06307f
C382 a_14220_6400.n15 VSS 0.06307f
C383 a_14220_6400.n16 VSS 0.18358f
C384 a_14220_6400.n17 VSS 0.09074f
C385 a_14220_6400.n18 VSS 0.09727f
C386 a_14220_6400.n19 VSS 0.09727f
C387 a_14220_6400.n20 VSS 0.09727f
C388 a_14220_6400.n21 VSS 0.09727f
C389 a_14220_6400.n22 VSS 0.09727f
C390 a_14220_6400.n23 VSS 0.09727f
C391 a_14220_6400.n24 VSS 0.09727f
C392 a_14220_6400.n25 VSS 0.06307f
C393 a_14220_6400.n26 VSS 0.09727f
C394 a_14220_6400.n27 VSS 0.09074f
C395 a_14220_6400.n28 VSS 0.18358f
C396 a_14220_6400.n29 VSS 0.09727f
C397 a_14220_6400.n30 VSS 0.09727f
C398 a_14220_6400.n31 VSS 0.09727f
C399 a_14220_6400.n32 VSS 0.06307f
C400 a_14220_6400.n33 VSS 0.06307f
C401 a_14220_6400.n34 VSS 0.06307f
C402 a_14220_6400.n35 VSS 0.09727f
C403 a_14220_6400.n36 VSS 0.09727f
C404 a_14220_6400.n37 VSS 0.09727f
C405 a_14220_6400.n38 VSS 0.05314f
C406 a_14220_6400.n39 VSS 0.51991f
C407 a_14220_6400.n40 VSS 0.05314f
C408 a_14220_6400.n41 VSS 0.06307f
C409 a_14220_6400.n42 VSS 0.06307f
C410 a_14220_6400.n43 VSS 0.06307f
C411 a_14220_6400.n44 VSS 0.06307f
C412 a_14220_6400.n45 VSS 0.18358f
C413 a_14220_6400.n46 VSS 0.09074f
C414 a_14220_6400.n47 VSS 0.09727f
C415 a_14220_6400.n48 VSS 0.09727f
C416 a_14220_6400.n49 VSS 0.09727f
C417 a_14220_6400.n50 VSS 0.09727f
C418 a_14220_6400.n51 VSS 0.09727f
C419 a_14220_6400.n52 VSS 0.09727f
C420 a_14220_6400.n53 VSS 0.09727f
C421 a_14220_6400.n54 VSS 0.06307f
C422 a_14220_6400.n55 VSS 0.09727f
C423 a_14220_6400.n56 VSS 0.09074f
C424 a_14220_6400.n57 VSS 0.18358f
C425 a_14220_6400.n58 VSS 0.09727f
C426 a_14220_6400.n59 VSS 0.09727f
C427 a_14220_6400.n60 VSS 0.09727f
C428 a_14220_6400.n61 VSS 0.06307f
C429 a_14220_6400.n62 VSS 0.06307f
C430 a_14220_6400.n63 VSS 0.06307f
C431 a_14220_6400.n64 VSS 0.09727f
C432 a_14220_6400.n65 VSS 0.09727f
C433 a_14220_6400.n66 VSS 0.09727f
C434 a_14220_6400.n67 VSS 0.05314f
C435 a_14220_6400.n68 VSS 0.4198f
C436 a_14220_6400.n69 VSS 1.97655f
C437 a_14220_6400.n70 VSS 1.51386f
C438 a_14220_6400.t6 VSS 0.7947f
C439 a_14220_6400.n71 VSS 0.23141f
C440 a_14220_6400.n72 VSS 0.16919f
C441 a_14220_6400.n73 VSS 0.57063f
C442 a_14220_6400.t0 VSS 0.20207f
C443 VSS.t93 VSS 0.09441f
C444 VSS.t31 VSS 0.09622f
C445 VSS.t101 VSS 0.09441f
C446 VSS.t91 VSS 0.09441f
C447 VSS.t53 VSS 0.09441f
C448 VSS.t99 VSS 0.09441f
C449 VSS.t3 VSS 0.09441f
C450 VSS.t51 VSS 0.09441f
C451 VSS.t35 VSS 0.09441f
C452 VSS.t1 VSS 0.09441f
C453 VSS.t97 VSS 0.09441f
C454 VSS.t33 VSS 0.09441f
C455 VSS.t153 VSS 0.09441f
C456 VSS.t95 VSS 0.09441f
C457 VSS.t37 VSS 0.09622f
C458 VSS.t151 VSS 0.09441f
C459 VSS.t43 VSS 0.09101f
C460 VSS.t69 VSS 0.09276f
C461 VSS.t149 VSS 0.09101f
C462 VSS.t5 VSS 0.09101f
C463 VSS.t41 VSS 0.09101f
C464 VSS.t195 VSS 0.09101f
C465 VSS.t7 VSS 0.09276f
C466 VSS.t39 VSS 0.09101f
C467 VSS.t81 VSS 0.09933f
C468 VSS.t83 VSS 0.10123f
C469 VSS.t71 VSS 0.09933f
C470 VSS.t73 VSS 0.09933f
C471 VSS.t45 VSS 0.09933f
C472 VSS.t47 VSS 0.09933f
C473 VSS.t9 VSS 0.10123f
C474 VSS.t11 VSS 0.09933f
C475 VSS.t199 VSS 0.0954f
C476 VSS.t103 VSS 0.09723f
C477 VSS.t183 VSS 0.0954f
C478 VSS.t197 VSS 0.0954f
C479 VSS.t145 VSS 0.0954f
C480 VSS.t181 VSS 0.0954f
C481 VSS.t49 VSS 0.09723f
C482 VSS.t143 VSS 0.0954f
C483 VSS.t157 VSS 0.07296f
C484 VSS.t159 VSS 0.07296f
C485 VSS.t121 VSS 0.0592f
C486 VSS.t119 VSS 0.06033f
C487 VSS.t123 VSS 0.06033f
C488 VSS.t117 VSS 0.0592f
C489 VSS.t163 VSS 0.0716f
C490 VSS.t161 VSS 0.07297f
C491 VSS.t155 VSS 0.07297f
C492 VSS.t165 VSS 0.0716f
C493 VSS.t187 VSS 0.09441f
C494 VSS.t125 VSS 0.09622f
C495 VSS.t131 VSS 0.09441f
C496 VSS.t185 VSS 0.09441f
C497 VSS.t135 VSS 0.09441f
C498 VSS.t129 VSS 0.09441f
C499 VSS.t193 VSS 0.09441f
C500 VSS.t133 VSS 0.09441f
C501 VSS.t139 VSS 0.09441f
C502 VSS.t191 VSS 0.09441f
C503 VSS.t169 VSS 0.09441f
C504 VSS.t137 VSS 0.09441f
C505 VSS.t15 VSS 0.09441f
C506 VSS.t167 VSS 0.09441f
C507 VSS.t85 VSS 0.09622f
C508 VSS.t13 VSS 0.09441f
C509 VSS.t147 VSS 0.09101f
C510 VSS.t141 VSS 0.09276f
C511 VSS.t75 VSS 0.09101f
C512 VSS.t17 VSS 0.09101f
C513 VSS.t57 VSS 0.09101f
C514 VSS.t25 VSS 0.09101f
C515 VSS.t59 VSS 0.09276f
C516 VSS.t55 VSS 0.09101f
C517 VSS.t63 VSS 0.09933f
C518 VSS.t127 VSS 0.10123f
C519 VSS.t21 VSS 0.09933f
C520 VSS.t61 VSS 0.09933f
C521 VSS.t67 VSS 0.09933f
C522 VSS.t19 VSS 0.09933f
C523 VSS.t23 VSS 0.10123f
C524 VSS.t65 VSS 0.09933f
C525 VSS.t27 VSS 0.0954f
C526 VSS.t29 VSS 0.09723f
C527 VSS.t87 VSS 0.0954f
C528 VSS.t89 VSS 0.0954f
C529 VSS.t77 VSS 0.0954f
C530 VSS.t79 VSS 0.0954f
C531 VSS.t189 VSS 0.09723f
C532 VSS.t171 VSS 0.0954f
C533 VSS.t105 VSS 0.07129f
C534 VSS.t109 VSS 0.07129f
C535 VSS.t175 VSS 0.0592f
C536 VSS.t173 VSS 0.06033f
C537 VSS.t179 VSS 0.06033f
C538 VSS.t177 VSS 0.0592f
C539 VSS.t113 VSS 0.06995f
C540 VSS.t111 VSS 0.0713f
C541 VSS.t107 VSS 0.0713f
C542 VSS.t115 VSS 0.06995f
C543 VDD.t24 VSS 2.13682f
C544 VDD.t4 VSS 0.10373f
C545 VDD.t6 VSS 0.10373f
C546 VDD.t40 VSS 0.10373f
C547 VDD.t42 VSS 0.10373f
C548 VDD.t64 VSS 0.10373f
C549 VDD.t66 VSS 0.10373f
C550 VDD.t20 VSS 0.10373f
C551 VDD.t22 VSS 0.10373f
C552 VDD.t0 VSS 0.10373f
C553 VDD.t2 VSS 0.10373f
C554 VDD.t36 VSS 0.10373f
C555 VDD.t38 VSS 0.10373f
C556 VDD.t60 VSS 0.10373f
C557 VDD.t62 VSS 0.10373f
C558 VDD.t18 VSS 0.58088f
C559 VDD.t50 VSS 0.58088f
C560 VDD.t72 VSS 0.10373f
C561 VDD.t74 VSS 0.10373f
C562 VDD.t148 VSS 0.10373f
C563 VDD.t150 VSS 0.10373f
C564 VDD.t76 VSS 0.10373f
C565 VDD.t78 VSS 0.10373f
C566 VDD.t102 VSS 0.58088f
C567 VDD.t8 VSS 0.58088f
C568 VDD.t10 VSS 0.10373f
C569 VDD.t152 VSS 0.10373f
C570 VDD.t154 VSS 0.10373f
C571 VDD.t120 VSS 0.10373f
C572 VDD.t122 VSS 0.10373f
C573 VDD.t138 VSS 0.10373f
C574 VDD.t140 VSS 0.58088f
C575 VDD.t80 VSS 0.58088f
C576 VDD.t68 VSS 0.10373f
C577 VDD.t70 VSS 0.10373f
C578 VDD.t26 VSS 0.10373f
C579 VDD.t28 VSS 0.10373f
C580 VDD.t184 VSS 0.10373f
C581 VDD.t186 VSS 0.10373f
C582 VDD.t132 VSS 0.58088f
C583 VDD.t174 VSS 0.58088f
C584 VDD.t180 VSS 0.58088f
C585 VDD.t118 VSS 0.58088f
C586 VDD.t114 VSS 0.10373f
C587 VDD.t116 VSS 0.10373f
C588 VDD.t112 VSS 0.58088f
C589 VDD.t172 VSS 0.58088f
C590 VDD.t182 VSS 0.10373f
C591 VDD.t178 VSS 0.10373f
C592 VDD.t176 VSS 0.58139f
C593 VDD.t63 VSS 0.10186f
C594 VDD.t19 VSS 0.10367f
C595 VDD.n1 VSS 0.03887f
C596 VDD.t39 VSS 0.10186f
C597 VDD.t61 VSS 0.10186f
C598 VDD.n2 VSS 0.03856f
C599 VDD.n3 VSS 0.01954f
C600 VDD.t3 VSS 0.10186f
C601 VDD.t37 VSS 0.10186f
C602 VDD.n4 VSS 0.03856f
C603 VDD.n5 VSS 0.01107f
C604 VDD.t23 VSS 0.10186f
C605 VDD.t1 VSS 0.10186f
C606 VDD.n6 VSS 0.03856f
C607 VDD.n7 VSS 0.01107f
C608 VDD.t67 VSS 0.10186f
C609 VDD.t21 VSS 0.10186f
C610 VDD.n8 VSS 0.03856f
C611 VDD.n9 VSS 0.01107f
C612 VDD.t43 VSS 0.10186f
C613 VDD.t65 VSS 0.10186f
C614 VDD.n10 VSS 0.03856f
C615 VDD.n11 VSS 0.01107f
C616 VDD.t7 VSS 0.10186f
C617 VDD.t41 VSS 0.10186f
C618 VDD.n12 VSS 0.03856f
C619 VDD.n13 VSS 0.01107f
C620 VDD.t25 VSS 0.10367f
C621 VDD.t5 VSS 0.10186f
C622 VDD.n14 VSS 0.03856f
C623 VDD.n15 VSS 0.05592f
C624 VDD.t79 VSS 0.09846f
C625 VDD.t103 VSS 0.10021f
C626 VDD.n16 VSS 0.03887f
C627 VDD.t151 VSS 0.09846f
C628 VDD.t77 VSS 0.09846f
C629 VDD.n17 VSS 0.03856f
C630 VDD.n18 VSS 0.01954f
C631 VDD.t75 VSS 0.09846f
C632 VDD.t149 VSS 0.09846f
C633 VDD.n19 VSS 0.03856f
C634 VDD.n20 VSS 0.01107f
C635 VDD.t51 VSS 0.10021f
C636 VDD.t73 VSS 0.09846f
C637 VDD.n21 VSS 0.03856f
C638 VDD.n22 VSS 0.0432f
C639 VDD.n23 VSS 0.82536f
C640 VDD.t139 VSS 0.10678f
C641 VDD.t141 VSS 0.10868f
C642 VDD.n24 VSS 0.03887f
C643 VDD.t121 VSS 0.10678f
C644 VDD.t123 VSS 0.10678f
C645 VDD.n25 VSS 0.03856f
C646 VDD.n26 VSS 0.01954f
C647 VDD.t153 VSS 0.10678f
C648 VDD.t155 VSS 0.10678f
C649 VDD.n27 VSS 0.03856f
C650 VDD.n28 VSS 0.01107f
C651 VDD.t9 VSS 0.10868f
C652 VDD.t11 VSS 0.10678f
C653 VDD.n29 VSS 0.03856f
C654 VDD.n30 VSS 0.0432f
C655 VDD.n31 VSS 0.42047f
C656 VDD.t187 VSS 0.10285f
C657 VDD.t133 VSS 0.10468f
C658 VDD.n32 VSS 0.03887f
C659 VDD.t29 VSS 0.10285f
C660 VDD.t185 VSS 0.10285f
C661 VDD.n33 VSS 0.03856f
C662 VDD.n34 VSS 0.01954f
C663 VDD.t71 VSS 0.10285f
C664 VDD.t27 VSS 0.10285f
C665 VDD.n35 VSS 0.03856f
C666 VDD.n36 VSS 0.01107f
C667 VDD.t81 VSS 0.10468f
C668 VDD.t69 VSS 0.10285f
C669 VDD.n37 VSS 0.03856f
C670 VDD.n38 VSS 0.0432f
C671 VDD.n39 VSS 0.42047f
C672 VDD.t175 VSS 0.08041f
C673 VDD.t181 VSS 0.08041f
C674 VDD.n40 VSS 0.06627f
C675 VDD.n41 VSS 0.36491f
C676 VDD.t117 VSS 0.06665f
C677 VDD.t113 VSS 0.06778f
C678 VDD.n42 VSS 0.03887f
C679 VDD.t119 VSS 0.06778f
C680 VDD.t115 VSS 0.06665f
C681 VDD.n43 VSS 0.03856f
C682 VDD.n44 VSS 0.05167f
C683 VDD.n45 VSS 0.30586f
C684 VDD.t179 VSS 0.07905f
C685 VDD.t177 VSS 0.08042f
C686 VDD.n46 VSS 0.03887f
C687 VDD.t173 VSS 0.08042f
C688 VDD.t183 VSS 0.07905f
C689 VDD.n47 VSS 0.03856f
C690 VDD.n48 VSS 0.05167f
C691 VDD.n49 VSS 0.40382f
C692 VDD.n50 VSS 27.4944f
C693 VDD.n51 VSS 45.5857f
C694 VDD.t124 VSS 2.13682f
C695 VDD.t134 VSS 0.10373f
C696 VDD.t136 VSS 0.10373f
C697 VDD.t104 VSS 0.10373f
C698 VDD.t106 VSS 0.10373f
C699 VDD.t30 VSS 0.10373f
C700 VDD.t32 VSS 0.10373f
C701 VDD.t52 VSS 0.10373f
C702 VDD.t54 VSS 0.10373f
C703 VDD.t196 VSS 0.10373f
C704 VDD.t198 VSS 0.10373f
C705 VDD.t56 VSS 0.10373f
C706 VDD.t58 VSS 0.10373f
C707 VDD.t128 VSS 0.10373f
C708 VDD.t130 VSS 0.10373f
C709 VDD.t12 VSS 0.58088f
C710 VDD.t146 VSS 0.58088f
C711 VDD.t44 VSS 0.10373f
C712 VDD.t160 VSS 0.10373f
C713 VDD.t162 VSS 0.10373f
C714 VDD.t156 VSS 0.10373f
C715 VDD.t158 VSS 0.10373f
C716 VDD.t142 VSS 0.10373f
C717 VDD.t144 VSS 0.58088f
C718 VDD.t126 VSS 0.58088f
C719 VDD.t14 VSS 0.10373f
C720 VDD.t16 VSS 0.10373f
C721 VDD.t46 VSS 0.10373f
C722 VDD.t48 VSS 0.10373f
C723 VDD.t108 VSS 0.10373f
C724 VDD.t110 VSS 0.10373f
C725 VDD.t34 VSS 0.58088f
C726 VDD.t164 VSS 0.58088f
C727 VDD.t166 VSS 0.10373f
C728 VDD.t168 VSS 0.10373f
C729 VDD.t170 VSS 0.10373f
C730 VDD.t98 VSS 0.10373f
C731 VDD.t100 VSS 0.10373f
C732 VDD.t94 VSS 0.10373f
C733 VDD.t96 VSS 0.58088f
C734 VDD.t92 VSS 0.58088f
C735 VDD.t84 VSS 0.58088f
C736 VDD.t194 VSS 0.58088f
C737 VDD.t188 VSS 0.10373f
C738 VDD.t192 VSS 0.10373f
C739 VDD.t190 VSS 0.58088f
C740 VDD.t82 VSS 0.58088f
C741 VDD.t90 VSS 0.10373f
C742 VDD.t88 VSS 0.10373f
C743 VDD.t86 VSS 0.58139f
C744 VDD.t131 VSS 0.10186f
C745 VDD.t13 VSS 0.10367f
C746 VDD.n52 VSS 0.03887f
C747 VDD.t59 VSS 0.10186f
C748 VDD.t129 VSS 0.10186f
C749 VDD.n53 VSS 0.03856f
C750 VDD.n54 VSS 0.01954f
C751 VDD.t199 VSS 0.10186f
C752 VDD.t57 VSS 0.10186f
C753 VDD.n55 VSS 0.03856f
C754 VDD.n56 VSS 0.01107f
C755 VDD.t55 VSS 0.10186f
C756 VDD.t197 VSS 0.10186f
C757 VDD.n57 VSS 0.03856f
C758 VDD.n58 VSS 0.01107f
C759 VDD.t33 VSS 0.10186f
C760 VDD.t53 VSS 0.10186f
C761 VDD.n59 VSS 0.03856f
C762 VDD.n60 VSS 0.01107f
C763 VDD.t107 VSS 0.10186f
C764 VDD.t31 VSS 0.10186f
C765 VDD.n61 VSS 0.03856f
C766 VDD.n62 VSS 0.01107f
C767 VDD.t137 VSS 0.10186f
C768 VDD.t105 VSS 0.10186f
C769 VDD.n63 VSS 0.03856f
C770 VDD.n64 VSS 0.01107f
C771 VDD.t125 VSS 0.10367f
C772 VDD.t135 VSS 0.10186f
C773 VDD.n65 VSS 0.03856f
C774 VDD.n66 VSS 0.05592f
C775 VDD.t143 VSS 0.09846f
C776 VDD.t145 VSS 0.10021f
C777 VDD.n67 VSS 0.03887f
C778 VDD.t157 VSS 0.09846f
C779 VDD.t159 VSS 0.09846f
C780 VDD.n68 VSS 0.03856f
C781 VDD.n69 VSS 0.01954f
C782 VDD.t161 VSS 0.09846f
C783 VDD.t163 VSS 0.09846f
C784 VDD.n70 VSS 0.03856f
C785 VDD.n71 VSS 0.01107f
C786 VDD.t147 VSS 0.10021f
C787 VDD.t45 VSS 0.09846f
C788 VDD.n72 VSS 0.03856f
C789 VDD.n73 VSS 0.0432f
C790 VDD.n74 VSS 0.82536f
C791 VDD.t111 VSS 0.10678f
C792 VDD.t35 VSS 0.10868f
C793 VDD.n75 VSS 0.03887f
C794 VDD.t49 VSS 0.10678f
C795 VDD.t109 VSS 0.10678f
C796 VDD.n76 VSS 0.03856f
C797 VDD.n77 VSS 0.01954f
C798 VDD.t17 VSS 0.10678f
C799 VDD.t47 VSS 0.10678f
C800 VDD.n78 VSS 0.03856f
C801 VDD.n79 VSS 0.01107f
C802 VDD.t127 VSS 0.10868f
C803 VDD.t15 VSS 0.10678f
C804 VDD.n80 VSS 0.03856f
C805 VDD.n81 VSS 0.0432f
C806 VDD.n82 VSS 0.42047f
C807 VDD.t95 VSS 0.10285f
C808 VDD.t97 VSS 0.10468f
C809 VDD.n83 VSS 0.03887f
C810 VDD.t99 VSS 0.10285f
C811 VDD.t101 VSS 0.10285f
C812 VDD.n84 VSS 0.03856f
C813 VDD.n85 VSS 0.01954f
C814 VDD.t169 VSS 0.10285f
C815 VDD.t171 VSS 0.10285f
C816 VDD.n86 VSS 0.03856f
C817 VDD.n87 VSS 0.01107f
C818 VDD.t165 VSS 0.10468f
C819 VDD.t167 VSS 0.10285f
C820 VDD.n88 VSS 0.03856f
C821 VDD.n89 VSS 0.0432f
C822 VDD.n90 VSS 0.42047f
C823 VDD.t93 VSS 0.07874f
C824 VDD.t85 VSS 0.07874f
C825 VDD.n91 VSS 0.06627f
C826 VDD.n92 VSS 0.36491f
C827 VDD.t193 VSS 0.06665f
C828 VDD.t191 VSS 0.06778f
C829 VDD.n93 VSS 0.03887f
C830 VDD.t195 VSS 0.06778f
C831 VDD.t189 VSS 0.06665f
C832 VDD.n94 VSS 0.03856f
C833 VDD.n95 VSS 0.05167f
C834 VDD.n96 VSS 0.30586f
C835 VDD.t89 VSS 0.07741f
C836 VDD.t87 VSS 0.07875f
C837 VDD.n97 VSS 0.03887f
C838 VDD.t83 VSS 0.07875f
C839 VDD.t91 VSS 0.07741f
C840 VDD.n98 VSS 0.03856f
C841 VDD.n99 VSS 0.05167f
C842 VDD.n100 VSS 0.40382f
C843 VDD.n101 VSS 27.1722f
C844 VDD.n102 VSS 45.9079f
C845 VDD.n104 VSS 0.01035f
C846 CLKN_HB.n0 VSS 0.2421f
C847 CLKN_HB.n1 VSS 0.20299f
C848 CLKN_HB.n2 VSS 0.8963f
C849 CLKN_HB.n3 VSS 0.06628f
C850 CLKN_HB.n4 VSS 0.07207f
C851 CLKN_HB.n5 VSS 0.07207f
C852 CLKN_HB.n6 VSS 0.06628f
C853 CLKN_HB.n7 VSS 0.31639f
C854 CLKN_HB.n8 VSS 0.06628f
C855 CLKN_HB.n9 VSS 0.07207f
C856 CLKN_HB.n10 VSS 0.07207f
C857 CLKN_HB.n11 VSS 0.06628f
C858 CLKN_HB.n12 VSS 0.25571f
C859 CLKN_HB.n13 VSS 0.65309f
C860 CLKN_HB.n14 VSS 1.23447f
C861 CLKN_H.n0 VSS 0.05609f
C862 CLKN_H.n1 VSS 0.06099f
C863 CLKN_H.n2 VSS 0.06099f
C864 CLKN_H.n3 VSS 0.05609f
C865 CLKN_H.n4 VSS 0.26774f
C866 CLKN_H.n5 VSS 0.05609f
C867 CLKN_H.n6 VSS 0.06099f
C868 CLKN_H.n7 VSS 0.06099f
C869 CLKN_H.n8 VSS 0.05609f
C870 CLKN_H.n9 VSS 0.21639f
C871 CLKN_H.n10 VSS 1.63646f
C872 O_CAPTURE_CLKB.t10 VSS 1.05948f
C873 O_CAPTURE_CLKB.t11 VSS 0.24624f
C874 O_CAPTURE_CLKB.t12 VSS 0.24624f
C875 O_CAPTURE_CLKB.n0 VSS 0.78079f
C876 O_CAPTURE_CLKB.n1 VSS 0.42917f
C877 O_CAPTURE_CLKB.t13 VSS 0.24624f
C878 O_CAPTURE_CLKB.t8 VSS 0.24624f
C879 O_CAPTURE_CLKB.n2 VSS 0.78079f
C880 O_CAPTURE_CLKB.n3 VSS 0.22404f
C881 O_CAPTURE_CLKB.t9 VSS 0.24624f
C882 O_CAPTURE_CLKB.t6 VSS 0.24624f
C883 O_CAPTURE_CLKB.n4 VSS 0.78079f
C884 O_CAPTURE_CLKB.n5 VSS 0.22404f
C885 O_CAPTURE_CLKB.t7 VSS 1.05247f
C886 O_CAPTURE_CLKB.n6 VSS 0.46353f
C887 O_CAPTURE_CLKB.t15 VSS 1.05761f
C888 O_CAPTURE_CLKB.t14 VSS 0.24624f
C889 O_CAPTURE_CLKB.t2 VSS 0.24624f
C890 O_CAPTURE_CLKB.n7 VSS 0.77503f
C891 O_CAPTURE_CLKB.n8 VSS 0.43679f
C892 O_CAPTURE_CLKB.t3 VSS 0.24624f
C893 O_CAPTURE_CLKB.t4 VSS 0.24624f
C894 O_CAPTURE_CLKB.n9 VSS 0.77503f
C895 O_CAPTURE_CLKB.n10 VSS 0.2298f
C896 O_CAPTURE_CLKB.t5 VSS 0.24624f
C897 O_CAPTURE_CLKB.t0 VSS 0.24624f
C898 O_CAPTURE_CLKB.n11 VSS 0.77503f
C899 O_CAPTURE_CLKB.n12 VSS 0.2298f
C900 O_CAPTURE_CLKB.t1 VSS 1.0506f
C901 O_CAPTURE_CLKB.n13 VSS 0.3143f
C902 O_CAPTURE_CLKB.n14 VSS 1.00866f
C903 O_CAPTURE_CLK.t15 VSS 1.02068f
C904 O_CAPTURE_CLK.t0 VSS 0.24346f
C905 O_CAPTURE_CLK.t1 VSS 0.24346f
C906 O_CAPTURE_CLK.n0 VSS 0.74605f
C907 O_CAPTURE_CLK.n1 VSS 0.41008f
C908 O_CAPTURE_CLK.t6 VSS 0.24346f
C909 O_CAPTURE_CLK.t7 VSS 0.24346f
C910 O_CAPTURE_CLK.n2 VSS 0.74605f
C911 O_CAPTURE_CLK.n3 VSS 0.21407f
C912 O_CAPTURE_CLK.t12 VSS 0.24346f
C913 O_CAPTURE_CLK.t13 VSS 0.24346f
C914 O_CAPTURE_CLK.n4 VSS 0.74605f
C915 O_CAPTURE_CLK.n5 VSS 0.21407f
C916 O_CAPTURE_CLK.t5 VSS 1.01398f
C917 O_CAPTURE_CLK.n6 VSS 0.44291f
C918 O_CAPTURE_CLK.t4 VSS 1.0189f
C919 O_CAPTURE_CLK.t10 VSS 0.24346f
C920 O_CAPTURE_CLK.t11 VSS 0.24346f
C921 O_CAPTURE_CLK.n7 VSS 0.74055f
C922 O_CAPTURE_CLK.n8 VSS 0.41736f
C923 O_CAPTURE_CLK.t2 VSS 0.24346f
C924 O_CAPTURE_CLK.t3 VSS 0.24346f
C925 O_CAPTURE_CLK.n9 VSS 0.74055f
C926 O_CAPTURE_CLK.n10 VSS 0.21957f
C927 O_CAPTURE_CLK.t8 VSS 0.24346f
C928 O_CAPTURE_CLK.t9 VSS 0.24346f
C929 O_CAPTURE_CLK.n11 VSS 0.74055f
C930 O_CAPTURE_CLK.n12 VSS 0.21957f
C931 O_CAPTURE_CLK.t14 VSS 1.01219f
C932 O_CAPTURE_CLK.n13 VSS 0.30032f
C933 O_CAPTURE_CLK.n14 VSS 1.53504f
C934 O_SENSE.t13 VSS 1.05832f
C935 O_SENSE.t20 VSS 0.24522f
C936 O_SENSE.t21 VSS 0.24522f
C937 O_SENSE.n0 VSS 0.78067f
C938 O_SENSE.n1 VSS 0.42911f
C939 O_SENSE.t10 VSS 0.24522f
C940 O_SENSE.t11 VSS 0.24522f
C941 O_SENSE.n2 VSS 0.78067f
C942 O_SENSE.n3 VSS 0.22401f
C943 O_SENSE.t3 VSS 0.24522f
C944 O_SENSE.t4 VSS 0.24522f
C945 O_SENSE.n4 VSS 0.78067f
C946 O_SENSE.n5 VSS 0.22401f
C947 O_SENSE.t5 VSS 0.24522f
C948 O_SENSE.t6 VSS 0.24522f
C949 O_SENSE.n6 VSS 0.78067f
C950 O_SENSE.n7 VSS 0.22401f
C951 O_SENSE.t28 VSS 0.24522f
C952 O_SENSE.t29 VSS 0.24522f
C953 O_SENSE.n8 VSS 0.78067f
C954 O_SENSE.n9 VSS 0.22401f
C955 O_SENSE.t7 VSS 0.24522f
C956 O_SENSE.t8 VSS 0.24522f
C957 O_SENSE.n10 VSS 0.78067f
C958 O_SENSE.n11 VSS 0.22401f
C959 O_SENSE.t16 VSS 0.24522f
C960 O_SENSE.t17 VSS 0.24522f
C961 O_SENSE.n12 VSS 0.78067f
C962 O_SENSE.n13 VSS 0.22401f
C963 O_SENSE.t0 VSS 1.05131f
C964 O_SENSE.n14 VSS 0.46346f
C965 O_SENSE.t9 VSS 1.05646f
C966 O_SENSE.t1 VSS 0.24522f
C967 O_SENSE.t2 VSS 0.24522f
C968 O_SENSE.n15 VSS 0.77491f
C969 O_SENSE.n16 VSS 0.43673f
C970 O_SENSE.t24 VSS 0.24522f
C971 O_SENSE.t25 VSS 0.24522f
C972 O_SENSE.n17 VSS 0.77491f
C973 O_SENSE.n18 VSS 0.22976f
C974 O_SENSE.t22 VSS 0.24522f
C975 O_SENSE.t23 VSS 0.24522f
C976 O_SENSE.n19 VSS 0.77491f
C977 O_SENSE.n20 VSS 0.22976f
C978 O_SENSE.t30 VSS 0.24522f
C979 O_SENSE.t31 VSS 0.24522f
C980 O_SENSE.n21 VSS 0.77491f
C981 O_SENSE.n22 VSS 0.22976f
C982 O_SENSE.t18 VSS 0.24522f
C983 O_SENSE.t19 VSS 0.24522f
C984 O_SENSE.n23 VSS 0.77491f
C985 O_SENSE.n24 VSS 0.22976f
C986 O_SENSE.t14 VSS 0.24522f
C987 O_SENSE.t15 VSS 0.24522f
C988 O_SENSE.n25 VSS 0.77491f
C989 O_SENSE.n26 VSS 0.22976f
C990 O_SENSE.t26 VSS 0.24522f
C991 O_SENSE.t27 VSS 0.24522f
C992 O_SENSE.n27 VSS 0.77491f
C993 O_SENSE.n28 VSS 0.22976f
C994 O_SENSE.t12 VSS 1.04944f
C995 O_SENSE.n29 VSS 0.31425f
C996 O_SENSE.n30 VSS 1.73221f
C997 CLKP_HB.n0 VSS 0.24778f
C998 CLKP_HB.n1 VSS 0.20775f
C999 CLKP_HB.n2 VSS 0.91731f
C1000 CLKP_HB.n3 VSS 0.06784f
C1001 CLKP_HB.n4 VSS 0.07376f
C1002 CLKP_HB.n5 VSS 0.07376f
C1003 CLKP_HB.n6 VSS 0.06784f
C1004 CLKP_HB.n7 VSS 0.32381f
C1005 CLKP_HB.n8 VSS 0.06784f
C1006 CLKP_HB.n9 VSS 0.07376f
C1007 CLKP_HB.n10 VSS 0.07376f
C1008 CLKP_HB.n11 VSS 0.06784f
C1009 CLKP_HB.n12 VSS 0.2617f
C1010 CLKP_HB.n13 VSS 0.66841f
C1011 CLKP_HB.n14 VSS 1.17032f
C1012 CLKP_H.n0 VSS 0.05609f
C1013 CLKP_H.n1 VSS 0.06099f
C1014 CLKP_H.n2 VSS 0.06099f
C1015 CLKP_H.n3 VSS 0.05609f
C1016 CLKP_H.n4 VSS 0.26774f
C1017 CLKP_H.n5 VSS 0.05609f
C1018 CLKP_H.n6 VSS 0.06099f
C1019 CLKP_H.n7 VSS 0.06099f
C1020 CLKP_H.n8 VSS 0.05609f
C1021 CLKP_H.n9 VSS 0.21639f
C1022 CLKP_H.n10 VSS 1.63646f
C1023 E_CAPTURE_CLKB.t6 VSS 1.05948f
C1024 E_CAPTURE_CLKB.t3 VSS 0.24624f
C1025 E_CAPTURE_CLKB.t4 VSS 0.24624f
C1026 E_CAPTURE_CLKB.n0 VSS 0.78079f
C1027 E_CAPTURE_CLKB.n1 VSS 0.42917f
C1028 E_CAPTURE_CLKB.t0 VSS 0.24624f
C1029 E_CAPTURE_CLKB.t1 VSS 0.24624f
C1030 E_CAPTURE_CLKB.n2 VSS 0.78079f
C1031 E_CAPTURE_CLKB.n3 VSS 0.22404f
C1032 E_CAPTURE_CLKB.t10 VSS 0.24624f
C1033 E_CAPTURE_CLKB.t11 VSS 0.24624f
C1034 E_CAPTURE_CLKB.n4 VSS 0.78079f
C1035 E_CAPTURE_CLKB.n5 VSS 0.22404f
C1036 E_CAPTURE_CLKB.t7 VSS 1.05247f
C1037 E_CAPTURE_CLKB.n6 VSS 0.46353f
C1038 E_CAPTURE_CLKB.t2 VSS 1.05761f
C1039 E_CAPTURE_CLKB.t8 VSS 0.24624f
C1040 E_CAPTURE_CLKB.t9 VSS 0.24624f
C1041 E_CAPTURE_CLKB.n7 VSS 0.77503f
C1042 E_CAPTURE_CLKB.n8 VSS 0.43679f
C1043 E_CAPTURE_CLKB.t12 VSS 0.24624f
C1044 E_CAPTURE_CLKB.t13 VSS 0.24624f
C1045 E_CAPTURE_CLKB.n9 VSS 0.77503f
C1046 E_CAPTURE_CLKB.n10 VSS 0.2298f
C1047 E_CAPTURE_CLKB.t14 VSS 0.24624f
C1048 E_CAPTURE_CLKB.t15 VSS 0.24624f
C1049 E_CAPTURE_CLKB.n11 VSS 0.77503f
C1050 E_CAPTURE_CLKB.n12 VSS 0.2298f
C1051 E_CAPTURE_CLKB.t5 VSS 1.0506f
C1052 E_CAPTURE_CLKB.n13 VSS 0.3143f
C1053 E_CAPTURE_CLKB.n14 VSS 1.00866f
C1054 E_CAPTURE_CLK.t0 VSS 1.02068f
C1055 E_CAPTURE_CLK.t1 VSS 0.24346f
C1056 E_CAPTURE_CLK.t14 VSS 0.24346f
C1057 E_CAPTURE_CLK.n0 VSS 0.74605f
C1058 E_CAPTURE_CLK.n1 VSS 0.41008f
C1059 E_CAPTURE_CLK.t15 VSS 0.24346f
C1060 E_CAPTURE_CLK.t10 VSS 0.24346f
C1061 E_CAPTURE_CLK.n2 VSS 0.74605f
C1062 E_CAPTURE_CLK.n3 VSS 0.21407f
C1063 E_CAPTURE_CLK.t11 VSS 0.24346f
C1064 E_CAPTURE_CLK.t12 VSS 0.24346f
C1065 E_CAPTURE_CLK.n4 VSS 0.74605f
C1066 E_CAPTURE_CLK.n5 VSS 0.21407f
C1067 E_CAPTURE_CLK.t13 VSS 1.01398f
C1068 E_CAPTURE_CLK.n6 VSS 0.44291f
C1069 E_CAPTURE_CLK.t2 VSS 1.0189f
C1070 E_CAPTURE_CLK.t3 VSS 0.24346f
C1071 E_CAPTURE_CLK.t4 VSS 0.24346f
C1072 E_CAPTURE_CLK.n7 VSS 0.74055f
C1073 E_CAPTURE_CLK.n8 VSS 0.41736f
C1074 E_CAPTURE_CLK.t5 VSS 0.24346f
C1075 E_CAPTURE_CLK.t6 VSS 0.24346f
C1076 E_CAPTURE_CLK.n9 VSS 0.74055f
C1077 E_CAPTURE_CLK.n10 VSS 0.21957f
C1078 E_CAPTURE_CLK.t7 VSS 0.24346f
C1079 E_CAPTURE_CLK.t8 VSS 0.24346f
C1080 E_CAPTURE_CLK.n11 VSS 0.74055f
C1081 E_CAPTURE_CLK.n12 VSS 0.21957f
C1082 E_CAPTURE_CLK.t9 VSS 1.01219f
C1083 E_CAPTURE_CLK.n13 VSS 0.30032f
C1084 E_CAPTURE_CLK.n14 VSS 1.53504f
C1085 E_SENSE.t10 VSS 1.05832f
C1086 E_SENSE.t2 VSS 0.24522f
C1087 E_SENSE.t3 VSS 0.24522f
C1088 E_SENSE.n0 VSS 0.78067f
C1089 E_SENSE.n1 VSS 0.42911f
C1090 E_SENSE.t16 VSS 0.24522f
C1091 E_SENSE.t17 VSS 0.24522f
C1092 E_SENSE.n2 VSS 0.78067f
C1093 E_SENSE.n3 VSS 0.22401f
C1094 E_SENSE.t22 VSS 0.24522f
C1095 E_SENSE.t23 VSS 0.24522f
C1096 E_SENSE.n4 VSS 0.78067f
C1097 E_SENSE.n5 VSS 0.22401f
C1098 E_SENSE.t7 VSS 0.24522f
C1099 E_SENSE.t8 VSS 0.24522f
C1100 E_SENSE.n6 VSS 0.78067f
C1101 E_SENSE.n7 VSS 0.22401f
C1102 E_SENSE.t0 VSS 0.24522f
C1103 E_SENSE.t1 VSS 0.24522f
C1104 E_SENSE.n8 VSS 0.78067f
C1105 E_SENSE.n9 VSS 0.22401f
C1106 E_SENSE.t14 VSS 0.24522f
C1107 E_SENSE.t15 VSS 0.24522f
C1108 E_SENSE.n10 VSS 0.78067f
C1109 E_SENSE.n11 VSS 0.22401f
C1110 E_SENSE.t20 VSS 0.24522f
C1111 E_SENSE.t21 VSS 0.24522f
C1112 E_SENSE.n12 VSS 0.78067f
C1113 E_SENSE.n13 VSS 0.22401f
C1114 E_SENSE.t6 VSS 1.05131f
C1115 E_SENSE.n14 VSS 0.46346f
C1116 E_SENSE.t13 VSS 1.05646f
C1117 E_SENSE.t30 VSS 0.24522f
C1118 E_SENSE.t31 VSS 0.24522f
C1119 E_SENSE.n15 VSS 0.77491f
C1120 E_SENSE.n16 VSS 0.43673f
C1121 E_SENSE.t26 VSS 0.24522f
C1122 E_SENSE.t27 VSS 0.24522f
C1123 E_SENSE.n17 VSS 0.77491f
C1124 E_SENSE.n18 VSS 0.22976f
C1125 E_SENSE.t11 VSS 0.24522f
C1126 E_SENSE.t12 VSS 0.24522f
C1127 E_SENSE.n19 VSS 0.77491f
C1128 E_SENSE.n20 VSS 0.22976f
C1129 E_SENSE.t4 VSS 0.24522f
C1130 E_SENSE.t5 VSS 0.24522f
C1131 E_SENSE.n21 VSS 0.77491f
C1132 E_SENSE.n22 VSS 0.22976f
C1133 E_SENSE.t18 VSS 0.24522f
C1134 E_SENSE.t19 VSS 0.24522f
C1135 E_SENSE.n23 VSS 0.77491f
C1136 E_SENSE.n24 VSS 0.22976f
C1137 E_SENSE.t28 VSS 0.24522f
C1138 E_SENSE.t29 VSS 0.24522f
C1139 E_SENSE.n25 VSS 0.77491f
C1140 E_SENSE.n26 VSS 0.22976f
C1141 E_SENSE.t24 VSS 0.24522f
C1142 E_SENSE.t25 VSS 0.24522f
C1143 E_SENSE.n27 VSS 0.77491f
C1144 E_SENSE.n28 VSS 0.22976f
C1145 E_SENSE.t9 VSS 1.04944f
C1146 E_SENSE.n29 VSS 0.31425f
C1147 E_SENSE.n30 VSS 1.73221f
.ends
