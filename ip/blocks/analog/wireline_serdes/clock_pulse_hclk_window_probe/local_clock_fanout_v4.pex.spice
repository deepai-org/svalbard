* PEX produced using /foss/tools/sak/sak-pex.sh with m=3 and s=1 (extresist threshold=0 mOhm, minres=1 mOhm, mindelay=0 ps)
* NGSPICE file created from local_clock_fanout_pex.ext - technology: gf180mcuD

.subckt local_clock_fanout_pex CLKP_H CLKP_HB CLKN_H CLKN_HB VDD VSS E_SENSE E_CAPTURE_CLK
+ E_CAPTURE_CLKB O_SENSE O_CAPTURE_CLK O_CAPTURE_CLKB
X0 VSS.t111 a_2700_41600.t11 O_CAPTURE_CLKB.t14 VSS.t110 nfet_03v3 ad=2.08p pd=8.52u as=2.08p ps=8.52u w=8u l=0.28u
X1 VDD.t15 a_14220_41600.t49 O_SENSE.t1 VDD.t14 pfet_03v3 ad=2.08p pd=8.52u as=2.08p ps=8.52u w=8u l=0.28u
X2 O_CAPTURE_CLK.t14 a_4812_41600.t14 VSS.t163 VSS.t162 nfet_03v3 ad=2.08p pd=8.52u as=2.08p ps=8.52u w=8u l=0.28u
X3 VDD.t93 a_2700_41600.t17 O_CAPTURE_CLKB.t8 VDD.t92 pfet_03v3 ad=2.08p pd=8.52u as=2.08p ps=8.52u w=8u l=0.28u
X4 O_SENSE.t14 a_14220_41600.t34 VDD.t87 VDD.t86 pfet_03v3 ad=2.08p pd=8.52u as=2.08p ps=8.52u w=8u l=0.28u
X5 O_CAPTURE_CLKB.t6 a_2700_41600.t8 VSS.t55 VSS.t54 nfet_03v3 ad=3.52p pd=16.88u as=2.08p ps=8.52u w=8u l=0.28u
X6 a_6924_6400.t1 CLKP_HB.t6 VDD.t153 VDD.t152 pfet_03v3 ad=3.52p pd=16.88u as=2.08p ps=8.52u w=8u l=0.28u
X7 VSS.t17 a_4812_6400.t13 E_CAPTURE_CLK.t1 VSS.t16 nfet_03v3 ad=2.08p pd=8.52u as=2.08p ps=8.52u w=8u l=0.28u
X8 VDD.t47 a_14220_41600.t43 O_SENSE.t7 VDD.t46 pfet_03v3 ad=2.08p pd=8.52u as=2.08p ps=8.52u w=8u l=0.28u
X9 VDD.t263 a_14220_41600.t55 O_SENSE.t47 VDD.t262 pfet_03v3 ad=2.08p pd=8.52u as=2.08p ps=8.52u w=8u l=0.28u
X10 VSS.t197 a_14220_6400.t31 E_SENSE.t47 VSS.t196 nfet_03v3 ad=2.08p pd=8.52u as=3.52p ps=16.88u w=8u l=0.28u
X11 VSS.t73 a_4812_6400.t11 E_CAPTURE_CLK.t5 VSS.t72 nfet_03v3 ad=2.08p pd=8.52u as=2.08p ps=8.52u w=8u l=0.28u
X12 E_SENSE.t0 a_14220_6400.t58 VDD.t1 VDD.t0 pfet_03v3 ad=2.08p pd=8.52u as=2.08p ps=8.52u w=8u l=0.28u
X13 O_SENSE.t16 a_14220_41600.t18 VSS.t57 VSS.t56 nfet_03v3 ad=2.08p pd=8.52u as=2.08p ps=8.52u w=8u l=0.28u
X14 E_SENSE.t6 a_14220_6400.t56 VDD.t31 VDD.t30 pfet_03v3 ad=2.08p pd=8.52u as=2.08p ps=8.52u w=8u l=0.28u
X15 E_CAPTURE_CLKB.t7 a_2700_6400.t14 VSS.t129 VSS.t128 nfet_03v3 ad=2.08p pd=8.52u as=2.08p ps=8.52u w=8u l=0.28u
X16 O_SENSE.t24 a_14220_41600.t40 VDD.t169 VDD.t168 pfet_03v3 ad=2.08p pd=8.52u as=2.08p ps=8.52u w=8u l=0.28u
X17 O_SENSE.t26 a_14220_41600.t30 VSS.t117 VSS.t116 nfet_03v3 ad=2.08p pd=8.52u as=2.08p ps=8.52u w=8u l=0.28u
X18 VDD.t149 CLKP_HB.t7 a_6924_6400.t0 VDD.t148 pfet_03v3 ad=2.08p pd=8.52u as=3.52p ps=16.88u w=8u l=0.28u
X19 VSS.t11 a_14220_6400.t17 E_SENSE.t11 VSS.t10 nfet_03v3 ad=2.08p pd=8.52u as=2.08p ps=8.52u w=8u l=0.28u
X20 E_CAPTURE_CLK.t2 a_4812_6400.t14 VSS.t19 VSS.t18 nfet_03v3 ad=2.08p pd=8.52u as=2.08p ps=8.52u w=8u l=0.28u
X21 O_SENSE.t36 a_14220_41600.t52 VDD.t227 VDD.t226 pfet_03v3 ad=2.08p pd=8.52u as=2.08p ps=8.52u w=8u l=0.28u
X22 O_CAPTURE_CLKB.t4 a_2700_41600.t14 VSS.t33 VSS.t32 nfet_03v3 ad=2.08p pd=8.52u as=2.08p ps=8.52u w=8u l=0.28u
X23 E_CAPTURE_CLKB.t10 a_2700_6400.t12 VSS.t145 VSS.t144 nfet_03v3 ad=2.08p pd=8.52u as=2.08p ps=8.52u w=8u l=0.28u
X24 VDD.t43 a_4812_6400.t23 E_CAPTURE_CLK.t0 VDD.t42 pfet_03v3 ad=2.08p pd=8.52u as=3.52p ps=16.88u w=8u l=0.28u
X25 E_CAPTURE_CLK.t6 a_4812_6400.t12 VSS.t75 VSS.t74 nfet_03v3 ad=2.08p pd=8.52u as=2.08p ps=8.52u w=8u l=0.28u
X26 VDD.t3 a_14220_6400.t59 E_SENSE.t1 VDD.t2 pfet_03v3 ad=2.08p pd=8.52u as=2.08p ps=8.52u w=8u l=0.28u
X27 VDD.t33 a_14220_6400.t57 E_SENSE.t7 VDD.t32 pfet_03v3 ad=2.08p pd=8.52u as=2.08p ps=8.52u w=8u l=0.28u
X28 VDD.t255 a_14220_41600.t61 O_SENSE.t43 VDD.t254 pfet_03v3 ad=2.08p pd=8.52u as=2.08p ps=8.52u w=8u l=0.28u
X29 a_14220_41600.t9 a_6924_41600.t6 VSS.t69 VSS.t68 nfet_03v3 ad=2.08p pd=8.52u as=2.08p ps=8.52u w=8u l=0.28u
X30 E_SENSE.t36 a_14220_6400.t18 VSS.t131 VSS.t130 nfet_03v3 ad=2.08p pd=8.52u as=2.08p ps=8.52u w=8u l=0.28u
X31 VSS.t25 a_2700_6400.t15 E_CAPTURE_CLKB.t1 VSS.t24 nfet_03v3 ad=2.08p pd=8.52u as=3.52p ps=16.88u w=8u l=0.28u
X32 E_SENSE.t32 a_14220_6400.t24 VSS.t121 VSS.t120 nfet_03v3 ad=2.08p pd=8.52u as=2.08p ps=8.52u w=8u l=0.28u
X33 VSS.t139 a_2700_6400.t13 E_CAPTURE_CLKB.t8 VSS.t138 nfet_03v3 ad=2.08p pd=8.52u as=2.08p ps=8.52u w=8u l=0.28u
X34 VDD.t73 a_14220_6400.t51 E_SENSE.t15 VDD.t72 pfet_03v3 ad=2.08p pd=8.52u as=2.08p ps=8.52u w=8u l=0.28u
X35 a_14220_41600.t5 a_6924_41600.t12 VDD.t81 VDD.t80 pfet_03v3 ad=3.52p pd=16.88u as=2.08p ps=8.52u w=8u l=0.28u
X36 VDD.t167 a_14220_6400.t43 E_SENSE.t27 VDD.t166 pfet_03v3 ad=2.08p pd=8.52u as=2.08p ps=8.52u w=8u l=0.28u
X37 O_SENSE.t34 a_14220_41600.t58 VDD.t223 VDD.t222 pfet_03v3 ad=2.08p pd=8.52u as=2.08p ps=8.52u w=8u l=0.28u
X38 O_CAPTURE_CLK.t2 a_4812_41600.t12 VSS.t29 VSS.t28 nfet_03v3 ad=2.08p pd=8.52u as=2.08p ps=8.52u w=8u l=0.28u
X39 O_CAPTURE_CLK.t10 a_4812_41600.t18 VDD.t211 VDD.t210 pfet_03v3 ad=2.08p pd=8.52u as=2.08p ps=8.52u w=8u l=0.28u
X40 O_SENSE.t8 a_14220_41600.t32 VDD.t49 VDD.t48 pfet_03v3 ad=3.52p pd=16.88u as=2.08p ps=8.52u w=8u l=0.28u
X41 VSS.t123 a_14220_6400.t25 E_SENSE.t33 VSS.t122 nfet_03v3 ad=2.08p pd=8.52u as=2.08p ps=8.52u w=8u l=0.28u
X42 E_SENSE.t40 a_14220_6400.t52 VDD.t195 VDD.t194 pfet_03v3 ad=2.08p pd=8.52u as=2.08p ps=8.52u w=8u l=0.28u
X43 E_CAPTURE_CLK.t13 a_4812_6400.t16 VDD.t235 VDD.t234 pfet_03v3 ad=3.52p pd=16.88u as=2.08p ps=8.52u w=8u l=0.28u
X44 a_4812_41600.t5 CLKN_H.t2 VSS.t175 VSS.t174 nfet_03v3 ad=2.08p pd=8.52u as=2.08p ps=8.52u w=8u l=0.28u
X45 E_SENSE.t22 a_14220_6400.t44 VDD.t119 VDD.t118 pfet_03v3 ad=2.08p pd=8.52u as=2.08p ps=8.52u w=8u l=0.28u
X46 a_14220_41600.t2 a_6924_41600.t18 VDD.t55 VDD.t54 pfet_03v3 ad=2.08p pd=8.52u as=2.08p ps=8.52u w=8u l=0.28u
X47 VSS.t53 a_4812_41600.t9 O_CAPTURE_CLK.t5 VSS.t52 nfet_03v3 ad=2.08p pd=8.52u as=2.08p ps=8.52u w=8u l=0.28u
X48 E_SENSE.t14 a_14220_6400.t50 VDD.t71 VDD.t70 pfet_03v3 ad=2.08p pd=8.52u as=2.08p ps=8.52u w=8u l=0.28u
X49 a_4812_41600.t3 CLKN_H.t4 VDD.t237 VDD.t236 pfet_03v3 ad=3.52p pd=16.88u as=2.08p ps=8.52u w=8u l=0.28u
X50 E_CAPTURE_CLKB.t13 a_2700_6400.t8 VSS.t193 VSS.t192 nfet_03v3 ad=3.52p pd=16.88u as=2.08p ps=8.52u w=8u l=0.28u
X51 VSS.t155 CLKN_HB.t3 a_2700_41600.t6 VSS.t154 nfet_03v3 ad=2.08p pd=8.52u as=2.08p ps=8.52u w=8u l=0.28u
X52 a_6924_41600.t3 CLKN_HB.t0 VSS.t159 VSS.t158 nfet_03v3 ad=3.52p pd=16.88u as=2.08p ps=8.52u w=8u l=0.28u
X53 VDD.t21 a_2700_6400.t17 E_CAPTURE_CLKB.t0 VDD.t20 pfet_03v3 ad=2.08p pd=8.52u as=2.08p ps=8.52u w=8u l=0.28u
X54 VSS.t107 a_6924_41600.t9 a_14220_41600.t11 VSS.t106 nfet_03v3 ad=2.08p pd=8.52u as=2.08p ps=8.52u w=8u l=0.28u
X55 a_2700_6400.t5 CLKP_HB.t4 VSS.t99 VSS.t98 nfet_03v3 ad=2.08p pd=8.52u as=2.08p ps=8.52u w=8u l=0.28u
X56 E_SENSE.t30 a_14220_6400.t36 VDD.t181 VDD.t180 pfet_03v3 ad=2.08p pd=8.52u as=2.08p ps=8.52u w=8u l=0.28u
X57 VDD.t191 a_4812_6400.t17 E_CAPTURE_CLK.t9 VDD.t190 pfet_03v3 ad=2.08p pd=8.52u as=2.08p ps=8.52u w=8u l=0.28u
X58 VDD.t25 a_6924_41600.t15 a_14220_41600.t1 VDD.t24 pfet_03v3 ad=2.08p pd=8.52u as=2.08p ps=8.52u w=8u l=0.28u
X59 O_SENSE.t2 a_14220_41600.t38 VDD.t17 VDD.t16 pfet_03v3 ad=2.08p pd=8.52u as=2.08p ps=8.52u w=8u l=0.28u
X60 VDD.t143 CLKP_HB.t11 a_2700_6400.t0 VDD.t142 pfet_03v3 ad=2.08p pd=8.52u as=3.52p ps=16.88u w=8u l=0.28u
X61 a_14220_6400.t9 a_6924_6400.t8 VSS.t43 VSS.t42 nfet_03v3 ad=2.08p pd=8.52u as=2.08p ps=8.52u w=8u l=0.28u
X62 a_2700_6400.t7 CLKP_HB.t2 VSS.t97 VSS.t96 nfet_03v3 ad=3.52p pd=16.88u as=2.08p ps=8.52u w=8u l=0.28u
X63 O_CAPTURE_CLKB.t11 a_2700_41600.t12 VSS.t103 VSS.t102 nfet_03v3 ad=2.08p pd=8.52u as=2.08p ps=8.52u w=8u l=0.28u
X64 O_SENSE.t38 a_14220_41600.t50 VDD.t231 VDD.t230 pfet_03v3 ad=2.08p pd=8.52u as=2.08p ps=8.52u w=8u l=0.28u
X65 VSS.t165 a_4812_41600.t15 O_CAPTURE_CLK.t15 VSS.t164 nfet_03v3 ad=2.08p pd=8.52u as=3.52p ps=16.88u w=8u l=0.28u
X66 VDD.t249 a_14220_6400.t39 E_SENSE.t43 VDD.t248 pfet_03v3 ad=2.08p pd=8.52u as=2.08p ps=8.52u w=8u l=0.28u
X67 E_CAPTURE_CLKB.t12 a_2700_6400.t18 VDD.t245 VDD.t244 pfet_03v3 ad=2.08p pd=8.52u as=2.08p ps=8.52u w=8u l=0.28u
X68 a_4812_6400.t7 CLKP_H.t0 VSS.t83 VSS.t82 nfet_03v3 ad=3.52p pd=16.88u as=2.08p ps=8.52u w=8u l=0.28u
X69 VDD.t183 a_14220_6400.t37 E_SENSE.t31 VDD.t182 pfet_03v3 ad=2.08p pd=8.52u as=2.08p ps=8.52u w=8u l=0.28u
X70 VDD.t121 a_14220_6400.t45 E_SENSE.t23 VDD.t120 pfet_03v3 ad=2.08p pd=8.52u as=2.08p ps=8.52u w=8u l=0.28u
X71 VDD.t141 a_4812_41600.t21 O_CAPTURE_CLK.t7 VDD.t140 pfet_03v3 ad=2.08p pd=8.52u as=2.08p ps=8.52u w=8u l=0.28u
X72 VDD.t89 a_14220_41600.t35 O_SENSE.t15 VDD.t88 pfet_03v3 ad=2.08p pd=8.52u as=2.08p ps=8.52u w=8u l=0.28u
X73 VSS.t7 a_14220_41600.t25 O_SENSE.t5 VSS.t6 nfet_03v3 ad=2.08p pd=8.52u as=2.08p ps=8.52u w=8u l=0.28u
X74 VSS.t167 a_2700_41600.t9 O_CAPTURE_CLKB.t15 VSS.t166 nfet_03v3 ad=2.08p pd=8.52u as=2.08p ps=8.52u w=8u l=0.28u
X75 VSS.t45 a_6924_6400.t9 a_14220_6400.t10 VSS.t44 nfet_03v3 ad=2.08p pd=8.52u as=2.08p ps=8.52u w=8u l=0.28u
X76 VSS.t101 CLKP_HB.t3 a_2700_6400.t6 VSS.t100 nfet_03v3 ad=2.08p pd=8.52u as=2.08p ps=8.52u w=8u l=0.28u
X77 VDD.t97 a_14220_41600.t47 O_SENSE.t19 VDD.t96 pfet_03v3 ad=2.08p pd=8.52u as=2.08p ps=8.52u w=8u l=0.28u
X78 VSS.t77 CLKP_H.t3 a_4812_6400.t4 VSS.t76 nfet_03v3 ad=2.08p pd=8.52u as=3.52p ps=16.88u w=8u l=0.28u
X79 a_14220_6400.t13 a_6924_6400.t18 VDD.t125 VDD.t124 pfet_03v3 ad=2.08p pd=8.52u as=2.08p ps=8.52u w=8u l=0.28u
X80 O_SENSE.t44 a_14220_41600.t56 VDD.t257 VDD.t256 pfet_03v3 ad=2.08p pd=8.52u as=2.08p ps=8.52u w=8u l=0.28u
X81 VSS.t81 CLKP_H.t1 a_4812_6400.t6 VSS.t80 nfet_03v3 ad=2.08p pd=8.52u as=2.08p ps=8.52u w=8u l=0.28u
X82 VSS.t59 a_14220_41600.t19 O_SENSE.t17 VSS.t58 nfet_03v3 ad=2.08p pd=8.52u as=2.08p ps=8.52u w=8u l=0.28u
X83 a_4812_6400.t1 CLKP_H.t6 VDD.t131 VDD.t130 pfet_03v3 ad=2.08p pd=8.52u as=2.08p ps=8.52u w=8u l=0.28u
X84 a_2700_41600.t1 CLKN_HB.t10 VDD.t201 VDD.t200 pfet_03v3 ad=2.08p pd=8.52u as=2.08p ps=8.52u w=8u l=0.28u
X85 VSS.t119 a_14220_41600.t31 O_SENSE.t27 VSS.t118 nfet_03v3 ad=2.08p pd=8.52u as=3.52p ps=16.88u w=8u l=0.28u
X86 VDD.t171 a_14220_41600.t41 O_SENSE.t25 VDD.t170 pfet_03v3 ad=2.08p pd=8.52u as=2.08p ps=8.52u w=8u l=0.28u
X87 VDD.t39 a_6924_6400.t19 a_14220_6400.t2 VDD.t38 pfet_03v3 ad=2.08p pd=8.52u as=3.52p ps=16.88u w=8u l=0.28u
X88 VDD.t229 a_14220_41600.t53 O_SENSE.t37 VDD.t228 pfet_03v3 ad=2.08p pd=8.52u as=2.08p ps=8.52u w=8u l=0.28u
X89 O_SENSE.t10 a_14220_41600.t16 VSS.t21 VSS.t20 nfet_03v3 ad=3.52p pd=16.88u as=2.08p ps=8.52u w=8u l=0.28u
X90 O_SENSE.t40 a_14220_41600.t28 VSS.t189 VSS.t188 nfet_03v3 ad=2.08p pd=8.52u as=2.08p ps=8.52u w=8u l=0.28u
X91 a_6924_6400.t3 CLKP_HB.t0 VSS.t91 VSS.t90 nfet_03v3 ad=3.52p pd=16.88u as=2.08p ps=8.52u w=8u l=0.28u
X92 VDD.t105 a_6924_41600.t13 a_14220_41600.t8 VDD.t104 pfet_03v3 ad=2.08p pd=8.52u as=2.08p ps=8.52u w=8u l=0.28u
X93 a_14220_41600.t4 a_6924_41600.t4 VSS.t27 VSS.t26 nfet_03v3 ad=3.52p pd=16.88u as=2.08p ps=8.52u w=8u l=0.28u
X94 VDD.t213 a_4812_41600.t19 O_CAPTURE_CLK.t11 VDD.t212 pfet_03v3 ad=2.08p pd=8.52u as=2.08p ps=8.52u w=8u l=0.28u
X95 VSS.t95 CLKP_HB.t1 a_6924_6400.t2 VSS.t94 nfet_03v3 ad=2.08p pd=8.52u as=3.52p ps=16.88u w=8u l=0.28u
X96 a_14220_6400.t4 a_6924_6400.t12 VDD.t41 VDD.t40 pfet_03v3 ad=3.52p pd=16.88u as=2.08p ps=8.52u w=8u l=0.28u
X97 VSS.t169 a_4812_6400.t15 E_CAPTURE_CLK.t12 VSS.t168 nfet_03v3 ad=2.08p pd=8.52u as=3.52p ps=16.88u w=8u l=0.28u
X98 O_CAPTURE_CLK.t8 a_4812_41600.t10 VSS.t85 VSS.t84 nfet_03v3 ad=2.08p pd=8.52u as=2.08p ps=8.52u w=8u l=0.28u
X99 E_SENSE.t12 a_14220_6400.t60 VDD.t67 VDD.t66 pfet_03v3 ad=2.08p pd=8.52u as=2.08p ps=8.52u w=8u l=0.28u
X100 O_CAPTURE_CLK.t12 a_4812_41600.t16 VDD.t219 VDD.t218 pfet_03v3 ad=3.52p pd=16.88u as=2.08p ps=8.52u w=8u l=0.28u
X101 VSS.t133 a_14220_6400.t19 E_SENSE.t37 VSS.t132 nfet_03v3 ad=2.08p pd=8.52u as=2.08p ps=8.52u w=8u l=0.28u
X102 VSS.t183 a_14220_6400.t27 E_SENSE.t45 VSS.t182 nfet_03v3 ad=2.08p pd=8.52u as=2.08p ps=8.52u w=8u l=0.28u
X103 a_2700_41600.t3 CLKN_HB.t8 VDD.t203 VDD.t202 pfet_03v3 ad=3.52p pd=16.88u as=2.08p ps=8.52u w=8u l=0.28u
X104 VDD.t65 a_2700_41600.t23 O_CAPTURE_CLKB.t3 VDD.t64 pfet_03v3 ad=2.08p pd=8.52u as=3.52p ps=16.88u w=8u l=0.28u
X105 a_4812_41600.t7 CLKN_H.t0 VSS.t177 VSS.t176 nfet_03v3 ad=3.52p pd=16.88u as=2.08p ps=8.52u w=8u l=0.28u
X106 a_14220_41600.t6 a_6924_41600.t10 VSS.t49 VSS.t48 nfet_03v3 ad=2.08p pd=8.52u as=2.08p ps=8.52u w=8u l=0.28u
X107 a_14220_41600.t14 a_6924_41600.t16 VDD.t177 VDD.t176 pfet_03v3 ad=2.08p pd=8.52u as=2.08p ps=8.52u w=8u l=0.28u
X108 VSS.t89 a_6924_41600.t7 a_14220_41600.t10 VSS.t88 nfet_03v3 ad=2.08p pd=8.52u as=2.08p ps=8.52u w=8u l=0.28u
X109 E_SENSE.t4 a_14220_6400.t20 VSS.t1 VSS.t0 nfet_03v3 ad=2.08p pd=8.52u as=2.08p ps=8.52u w=8u l=0.28u
X110 E_SENSE.t38 a_14220_6400.t28 VSS.t141 VSS.t140 nfet_03v3 ad=2.08p pd=8.52u as=2.08p ps=8.52u w=8u l=0.28u
X111 E_CAPTURE_CLK.t11 a_4812_6400.t8 VSS.t161 VSS.t160 nfet_03v3 ad=3.52p pd=16.88u as=2.08p ps=8.52u w=8u l=0.28u
X112 O_SENSE.t20 a_14220_41600.t36 VDD.t99 VDD.t98 pfet_03v3 ad=2.08p pd=8.52u as=2.08p ps=8.52u w=8u l=0.28u
X113 O_SENSE.t28 a_14220_41600.t26 VSS.t125 VSS.t124 nfet_03v3 ad=2.08p pd=8.52u as=2.08p ps=8.52u w=8u l=0.28u
X114 E_SENSE.t44 a_14220_6400.t26 VSS.t181 VSS.t180 nfet_03v3 ad=2.08p pd=8.52u as=2.08p ps=8.52u w=8u l=0.28u
X115 VDD.t197 a_14220_6400.t53 E_SENSE.t41 VDD.t196 pfet_03v3 ad=2.08p pd=8.52u as=2.08p ps=8.52u w=8u l=0.28u
X116 O_SENSE.t0 a_14220_41600.t48 VDD.t13 VDD.t12 pfet_03v3 ad=2.08p pd=8.52u as=2.08p ps=8.52u w=8u l=0.28u
X117 VSS.t31 a_4812_41600.t13 O_CAPTURE_CLK.t3 VSS.t30 nfet_03v3 ad=2.08p pd=8.52u as=2.08p ps=8.52u w=8u l=0.28u
X118 VSS.t199 a_2700_6400.t9 E_CAPTURE_CLKB.t15 VSS.t198 nfet_03v3 ad=2.08p pd=8.52u as=2.08p ps=8.52u w=8u l=0.28u
X119 VDD.t51 a_14220_41600.t33 O_SENSE.t9 VDD.t50 pfet_03v3 ad=2.08p pd=8.52u as=2.08p ps=8.52u w=8u l=0.28u
X120 VSS.t137 a_14220_41600.t23 O_SENSE.t31 VSS.t136 nfet_03v3 ad=2.08p pd=8.52u as=2.08p ps=8.52u w=8u l=0.28u
X121 VSS.t185 a_4812_6400.t9 E_CAPTURE_CLK.t14 VSS.t184 nfet_03v3 ad=2.08p pd=8.52u as=2.08p ps=8.52u w=8u l=0.28u
X122 VSS.t93 CLKP_HB.t5 a_2700_6400.t4 VSS.t92 nfet_03v3 ad=2.08p pd=8.52u as=3.52p ps=16.88u w=8u l=0.28u
X123 E_SENSE.t20 a_14220_6400.t54 VDD.t115 VDD.t114 pfet_03v3 ad=2.08p pd=8.52u as=2.08p ps=8.52u w=8u l=0.28u
X124 E_CAPTURE_CLK.t10 a_4812_6400.t18 VDD.t193 VDD.t192 pfet_03v3 ad=2.08p pd=8.52u as=2.08p ps=8.52u w=8u l=0.28u
X125 VDD.t205 CLKN_HB.t11 a_2700_41600.t0 VDD.t204 pfet_03v3 ad=2.08p pd=8.52u as=3.52p ps=16.88u w=8u l=0.28u
X126 VDD.t85 a_14220_41600.t45 O_SENSE.t13 VDD.t84 pfet_03v3 ad=2.08p pd=8.52u as=2.08p ps=8.52u w=8u l=0.28u
X127 VSS.t3 a_14220_6400.t21 E_SENSE.t5 VSS.t2 nfet_03v3 ad=2.08p pd=8.52u as=2.08p ps=8.52u w=8u l=0.28u
X128 VDD.t207 CLKN_HB.t7 a_6924_41600.t0 VDD.t206 pfet_03v3 ad=2.08p pd=8.52u as=3.52p ps=16.88u w=8u l=0.28u
X129 a_2700_41600.t5 CLKN_HB.t4 VSS.t153 VSS.t152 nfet_03v3 ad=2.08p pd=8.52u as=2.08p ps=8.52u w=8u l=0.28u
X130 E_CAPTURE_CLKB.t4 a_2700_6400.t10 VSS.t65 VSS.t64 nfet_03v3 ad=2.08p pd=8.52u as=2.08p ps=8.52u w=8u l=0.28u
X131 E_SENSE.t28 a_14220_6400.t40 VDD.t173 VDD.t172 pfet_03v3 ad=2.08p pd=8.52u as=2.08p ps=8.52u w=8u l=0.28u
X132 VSS.t23 a_14220_41600.t17 O_SENSE.t11 VSS.t22 nfet_03v3 ad=2.08p pd=8.52u as=2.08p ps=8.52u w=8u l=0.28u
X133 VDD.t79 a_2700_6400.t19 E_CAPTURE_CLKB.t3 VDD.t78 pfet_03v3 ad=2.08p pd=8.52u as=2.08p ps=8.52u w=8u l=0.28u
X134 E_SENSE.t42 a_14220_6400.t38 VDD.t247 VDD.t246 pfet_03v3 ad=2.08p pd=8.52u as=2.08p ps=8.52u w=8u l=0.28u
X135 E_SENSE.t8 a_14220_6400.t46 VDD.t35 VDD.t34 pfet_03v3 ad=2.08p pd=8.52u as=2.08p ps=8.52u w=8u l=0.28u
X136 VSS.t191 a_14220_41600.t29 O_SENSE.t41 VSS.t190 nfet_03v3 ad=2.08p pd=8.52u as=2.08p ps=8.52u w=8u l=0.28u
X137 VDD.t29 a_2700_41600.t21 O_CAPTURE_CLKB.t1 VDD.t28 pfet_03v3 ad=2.08p pd=8.52u as=2.08p ps=8.52u w=8u l=0.28u
X138 a_14220_6400.t14 a_6924_6400.t10 VSS.t71 VSS.t70 nfet_03v3 ad=2.08p pd=8.52u as=2.08p ps=8.52u w=8u l=0.28u
X139 VDD.t233 a_14220_41600.t51 O_SENSE.t39 VDD.t232 pfet_03v3 ad=2.08p pd=8.52u as=2.08p ps=8.52u w=8u l=0.28u
X140 a_4812_6400.t5 CLKP_H.t2 VSS.t79 VSS.t78 nfet_03v3 ad=2.08p pd=8.52u as=2.08p ps=8.52u w=8u l=0.28u
X141 VDD.t37 a_14220_6400.t47 E_SENSE.t9 VDD.t36 pfet_03v3 ad=2.08p pd=8.52u as=2.08p ps=8.52u w=8u l=0.28u
X142 O_CAPTURE_CLKB.t9 a_2700_41600.t18 VDD.t107 VDD.t106 pfet_03v3 ad=2.08p pd=8.52u as=2.08p ps=8.52u w=8u l=0.28u
X143 VSS.t67 a_6924_41600.t5 a_14220_41600.t7 VSS.t66 nfet_03v3 ad=2.08p pd=8.52u as=2.08p ps=8.52u w=8u l=0.28u
X144 VSS.t15 a_6924_6400.t11 a_14220_6400.t5 VSS.t14 nfet_03v3 ad=2.08p pd=8.52u as=3.52p ps=16.88u w=8u l=0.28u
X145 VDD.t157 a_14220_6400.t33 E_SENSE.t25 VDD.t156 pfet_03v3 ad=2.08p pd=8.52u as=2.08p ps=8.52u w=8u l=0.28u
X146 O_SENSE.t12 a_14220_41600.t44 VDD.t83 VDD.t82 pfet_03v3 ad=2.08p pd=8.52u as=2.08p ps=8.52u w=8u l=0.28u
X147 VSS.t87 a_4812_41600.t11 O_CAPTURE_CLK.t9 VSS.t86 nfet_03v3 ad=2.08p pd=8.52u as=2.08p ps=8.52u w=8u l=0.28u
X148 VDD.t239 CLKN_H.t7 a_4812_41600.t0 VDD.t238 pfet_03v3 ad=2.08p pd=8.52u as=3.52p ps=16.88u w=8u l=0.28u
X149 E_SENSE.t34 a_14220_6400.t34 VDD.t185 VDD.t184 pfet_03v3 ad=2.08p pd=8.52u as=2.08p ps=8.52u w=8u l=0.28u
X150 O_CAPTURE_CLK.t4 a_4812_41600.t8 VSS.t51 VSS.t50 nfet_03v3 ad=3.52p pd=16.88u as=2.08p ps=8.52u w=8u l=0.28u
X151 E_SENSE.t24 a_14220_6400.t32 VDD.t155 VDD.t154 pfet_03v3 ad=3.52p pd=16.88u as=2.08p ps=8.52u w=8u l=0.28u
X152 a_2700_41600.t7 CLKN_HB.t2 VSS.t157 VSS.t156 nfet_03v3 ad=3.52p pd=16.88u as=2.08p ps=8.52u w=8u l=0.28u
X153 VSS.t35 a_2700_41600.t15 O_CAPTURE_CLKB.t5 VSS.t34 nfet_03v3 ad=2.08p pd=8.52u as=3.52p ps=16.88u w=8u l=0.28u
X154 a_14220_6400.t11 a_6924_6400.t4 VSS.t47 VSS.t46 nfet_03v3 ad=3.52p pd=16.88u as=2.08p ps=8.52u w=8u l=0.28u
X155 VDD.t75 a_6924_6400.t15 a_14220_6400.t6 VDD.t74 pfet_03v3 ad=2.08p pd=8.52u as=2.08p ps=8.52u w=8u l=0.28u
X156 a_14220_41600.t13 a_6924_41600.t8 VSS.t115 VSS.t114 nfet_03v3 ad=2.08p pd=8.52u as=2.08p ps=8.52u w=8u l=0.28u
X157 VDD.t9 a_6924_6400.t13 a_14220_6400.t0 VDD.t8 pfet_03v3 ad=2.08p pd=8.52u as=2.08p ps=8.52u w=8u l=0.28u
X158 O_SENSE.t32 a_14220_41600.t62 VDD.t215 VDD.t214 pfet_03v3 ad=2.08p pd=8.52u as=2.08p ps=8.52u w=8u l=0.28u
X159 VDD.t69 a_14220_6400.t61 E_SENSE.t13 VDD.t68 pfet_03v3 ad=2.08p pd=8.52u as=2.08p ps=8.52u w=8u l=0.28u
X160 a_14220_6400.t1 a_6924_6400.t14 VDD.t11 VDD.t10 pfet_03v3 ad=2.08p pd=8.52u as=2.08p ps=8.52u w=8u l=0.28u
X161 VDD.t225 a_14220_41600.t59 O_SENSE.t35 VDD.t224 pfet_03v3 ad=2.08p pd=8.52u as=2.08p ps=8.52u w=8u l=0.28u
X162 O_SENSE.t4 a_14220_41600.t24 VSS.t5 VSS.t4 nfet_03v3 ad=2.08p pd=8.52u as=2.08p ps=8.52u w=8u l=0.28u
X163 O_SENSE.t18 a_14220_41600.t46 VDD.t95 VDD.t94 pfet_03v3 ad=2.08p pd=8.52u as=2.08p ps=8.52u w=8u l=0.28u
X164 E_SENSE.t18 a_14220_6400.t62 VDD.t111 VDD.t110 pfet_03v3 ad=2.08p pd=8.52u as=2.08p ps=8.52u w=8u l=0.28u
X165 VSS.t151 CLKN_HB.t5 a_2700_41600.t4 VSS.t150 nfet_03v3 ad=2.08p pd=8.52u as=3.52p ps=16.88u w=8u l=0.28u
X166 VSS.t63 a_14220_41600.t21 O_SENSE.t23 VSS.t62 nfet_03v3 ad=2.08p pd=8.52u as=2.08p ps=8.52u w=8u l=0.28u
X167 VDD.t241 CLKN_H.t5 a_4812_41600.t2 VDD.t240 pfet_03v3 ad=2.08p pd=8.52u as=2.08p ps=8.52u w=8u l=0.28u
X168 VDD.t57 a_6924_41600.t19 a_14220_41600.t3 VDD.t56 pfet_03v3 ad=2.08p pd=8.52u as=3.52p ps=16.88u w=8u l=0.28u
X169 VSS.t143 a_14220_6400.t29 E_SENSE.t39 VSS.t142 nfet_03v3 ad=2.08p pd=8.52u as=2.08p ps=8.52u w=8u l=0.28u
X170 VSS.t149 CLKN_HB.t1 a_6924_41600.t2 VSS.t148 nfet_03v3 ad=2.08p pd=8.52u as=3.52p ps=16.88u w=8u l=0.28u
X171 VSS.t105 a_2700_41600.t13 O_CAPTURE_CLKB.t12 VSS.t104 nfet_03v3 ad=2.08p pd=8.52u as=2.08p ps=8.52u w=8u l=0.28u
X172 VSS.t127 a_14220_41600.t27 O_SENSE.t29 VSS.t126 nfet_03v3 ad=2.08p pd=8.52u as=2.08p ps=8.52u w=8u l=0.28u
X173 E_SENSE.t46 a_14220_6400.t30 VSS.t195 VSS.t194 nfet_03v3 ad=2.08p pd=8.52u as=2.08p ps=8.52u w=8u l=0.28u
X174 E_CAPTURE_CLK.t15 a_4812_6400.t10 VSS.t187 VSS.t186 nfet_03v3 ad=2.08p pd=8.52u as=2.08p ps=8.52u w=8u l=0.28u
X175 VDD.t127 a_4812_6400.t21 E_CAPTURE_CLK.t3 VDD.t126 pfet_03v3 ad=2.08p pd=8.52u as=2.08p ps=8.52u w=8u l=0.28u
X176 VDD.t109 a_2700_41600.t19 O_CAPTURE_CLKB.t10 VDD.t108 pfet_03v3 ad=2.08p pd=8.52u as=2.08p ps=8.52u w=8u l=0.28u
X177 VDD.t117 a_14220_6400.t55 E_SENSE.t21 VDD.t116 pfet_03v3 ad=2.08p pd=8.52u as=2.08p ps=8.52u w=8u l=0.28u
X178 VDD.t159 a_4812_6400.t19 E_CAPTURE_CLK.t7 VDD.t158 pfet_03v3 ad=2.08p pd=8.52u as=2.08p ps=8.52u w=8u l=0.28u
X179 O_CAPTURE_CLK.t0 a_4812_41600.t22 VDD.t59 VDD.t58 pfet_03v3 ad=2.08p pd=8.52u as=2.08p ps=8.52u w=8u l=0.28u
X180 O_CAPTURE_CLKB.t13 a_2700_41600.t10 VSS.t109 VSS.t108 nfet_03v3 ad=2.08p pd=8.52u as=2.08p ps=8.52u w=8u l=0.28u
X181 E_SENSE.t10 a_14220_6400.t16 VSS.t9 VSS.t8 nfet_03v3 ad=3.52p pd=16.88u as=2.08p ps=8.52u w=8u l=0.28u
X182 E_SENSE.t16 a_14220_6400.t22 VSS.t37 VSS.t36 nfet_03v3 ad=2.08p pd=8.52u as=2.08p ps=8.52u w=8u l=0.28u
X183 E_CAPTURE_CLKB.t6 a_2700_6400.t22 VDD.t163 VDD.t162 pfet_03v3 ad=2.08p pd=8.52u as=2.08p ps=8.52u w=8u l=0.28u
X184 VSS.t179 a_2700_6400.t11 E_CAPTURE_CLKB.t11 VSS.t178 nfet_03v3 ad=2.08p pd=8.52u as=2.08p ps=8.52u w=8u l=0.28u
X185 VDD.t175 a_14220_6400.t41 E_SENSE.t29 VDD.t174 pfet_03v3 ad=2.08p pd=8.52u as=2.08p ps=8.52u w=8u l=0.28u
X186 O_CAPTURE_CLKB.t7 a_2700_41600.t16 VDD.t91 VDD.t90 pfet_03v3 ad=3.52p pd=16.88u as=2.08p ps=8.52u w=8u l=0.28u
X187 E_CAPTURE_CLKB.t14 a_2700_6400.t20 VDD.t251 VDD.t250 pfet_03v3 ad=2.08p pd=8.52u as=2.08p ps=8.52u w=8u l=0.28u
X188 E_CAPTURE_CLK.t4 a_4812_6400.t22 VDD.t129 VDD.t128 pfet_03v3 ad=2.08p pd=8.52u as=2.08p ps=8.52u w=8u l=0.28u
X189 VDD.t259 a_14220_41600.t57 O_SENSE.t45 VDD.t258 pfet_03v3 ad=2.08p pd=8.52u as=2.08p ps=8.52u w=8u l=0.28u
X190 E_CAPTURE_CLK.t8 a_4812_6400.t20 VDD.t161 VDD.t160 pfet_03v3 ad=2.08p pd=8.52u as=2.08p ps=8.52u w=8u l=0.28u
X191 O_SENSE.t22 a_14220_41600.t20 VSS.t61 VSS.t60 nfet_03v3 ad=2.08p pd=8.52u as=2.08p ps=8.52u w=8u l=0.28u
X192 VSS.t171 CLKN_H.t3 a_4812_41600.t4 VSS.t170 nfet_03v3 ad=2.08p pd=8.52u as=3.52p ps=16.88u w=8u l=0.28u
X193 VDD.t189 a_2700_6400.t23 E_CAPTURE_CLKB.t9 VDD.t188 pfet_03v3 ad=2.08p pd=8.52u as=3.52p ps=16.88u w=8u l=0.28u
X194 VSS.t39 a_14220_6400.t23 E_SENSE.t17 VSS.t38 nfet_03v3 ad=2.08p pd=8.52u as=2.08p ps=8.52u w=8u l=0.28u
X195 O_SENSE.t6 a_14220_41600.t42 VDD.t45 VDD.t44 pfet_03v3 ad=2.08p pd=8.52u as=2.08p ps=8.52u w=8u l=0.28u
X196 E_SENSE.t26 a_14220_6400.t42 VDD.t165 VDD.t164 pfet_03v3 ad=2.08p pd=8.52u as=2.08p ps=8.52u w=8u l=0.28u
X197 O_SENSE.t46 a_14220_41600.t54 VDD.t261 VDD.t260 pfet_03v3 ad=2.08p pd=8.52u as=2.08p ps=8.52u w=8u l=0.28u
X198 VDD.t53 a_2700_6400.t21 E_CAPTURE_CLKB.t2 VDD.t52 pfet_03v3 ad=2.08p pd=8.52u as=2.08p ps=8.52u w=8u l=0.28u
X199 E_SENSE.t2 a_14220_6400.t48 VDD.t5 VDD.t4 pfet_03v3 ad=2.08p pd=8.52u as=2.08p ps=8.52u w=8u l=0.28u
X200 O_CAPTURE_CLKB.t2 a_2700_41600.t22 VDD.t63 VDD.t62 pfet_03v3 ad=2.08p pd=8.52u as=2.08p ps=8.52u w=8u l=0.28u
X201 VDD.t217 a_14220_41600.t63 O_SENSE.t33 VDD.t216 pfet_03v3 ad=2.08p pd=8.52u as=3.52p ps=16.88u w=8u l=0.28u
X202 VDD.t19 a_14220_41600.t39 O_SENSE.t3 VDD.t18 pfet_03v3 ad=2.08p pd=8.52u as=2.08p ps=8.52u w=8u l=0.28u
X203 a_14220_41600.t0 a_6924_41600.t14 VDD.t23 VDD.t22 pfet_03v3 ad=2.08p pd=8.52u as=2.08p ps=8.52u w=8u l=0.28u
X204 VDD.t7 a_14220_6400.t49 E_SENSE.t3 VDD.t6 pfet_03v3 ad=2.08p pd=8.52u as=2.08p ps=8.52u w=8u l=0.28u
X205 O_SENSE.t42 a_14220_41600.t60 VDD.t253 VDD.t252 pfet_03v3 ad=2.08p pd=8.52u as=2.08p ps=8.52u w=8u l=0.28u
X206 E_CAPTURE_CLKB.t5 a_2700_6400.t16 VDD.t103 VDD.t102 pfet_03v3 ad=3.52p pd=16.88u as=2.08p ps=8.52u w=8u l=0.28u
X207 VDD.t187 a_14220_6400.t35 E_SENSE.t35 VDD.t186 pfet_03v3 ad=2.08p pd=8.52u as=2.08p ps=8.52u w=8u l=0.28u
X208 O_CAPTURE_CLK.t6 a_4812_41600.t20 VDD.t139 VDD.t138 pfet_03v3 ad=2.08p pd=8.52u as=2.08p ps=8.52u w=8u l=0.28u
X209 a_2700_6400.t1 CLKP_HB.t10 VDD.t145 VDD.t144 pfet_03v3 ad=2.08p pd=8.52u as=2.08p ps=8.52u w=8u l=0.28u
X210 VSS.t147 a_6924_6400.t7 a_14220_6400.t15 VSS.t146 nfet_03v3 ad=2.08p pd=8.52u as=2.08p ps=8.52u w=8u l=0.28u
X211 a_2700_6400.t3 CLKP_HB.t8 VDD.t151 VDD.t150 pfet_03v3 ad=3.52p pd=16.88u as=2.08p ps=8.52u w=8u l=0.28u
X212 VSS.t13 a_6924_6400.t5 a_14220_6400.t3 VSS.t12 nfet_03v3 ad=2.08p pd=8.52u as=2.08p ps=8.52u w=8u l=0.28u
X213 a_14220_6400.t7 a_6924_6400.t16 VDD.t77 VDD.t76 pfet_03v3 ad=2.08p pd=8.52u as=2.08p ps=8.52u w=8u l=0.28u
X214 O_SENSE.t30 a_14220_41600.t22 VSS.t135 VSS.t134 nfet_03v3 ad=2.08p pd=8.52u as=2.08p ps=8.52u w=8u l=0.28u
X215 a_4812_41600.t1 CLKN_H.t6 VDD.t243 VDD.t242 pfet_03v3 ad=2.08p pd=8.52u as=2.08p ps=8.52u w=8u l=0.28u
X216 VDD.t221 a_4812_41600.t17 O_CAPTURE_CLK.t13 VDD.t220 pfet_03v3 ad=2.08p pd=8.52u as=2.08p ps=8.52u w=8u l=0.28u
X217 a_4812_6400.t3 CLKP_H.t4 VDD.t137 VDD.t136 pfet_03v3 ad=3.52p pd=16.88u as=2.08p ps=8.52u w=8u l=0.28u
X218 VSS.t173 CLKN_H.t1 a_4812_41600.t6 VSS.t172 nfet_03v3 ad=2.08p pd=8.52u as=2.08p ps=8.52u w=8u l=0.28u
X219 VSS.t113 a_6924_41600.t11 a_14220_41600.t12 VSS.t112 nfet_03v3 ad=2.08p pd=8.52u as=3.52p ps=16.88u w=8u l=0.28u
X220 VDD.t209 CLKN_HB.t9 a_2700_41600.t2 VDD.t208 pfet_03v3 ad=2.08p pd=8.52u as=2.08p ps=8.52u w=8u l=0.28u
X221 a_6924_41600.t1 CLKN_HB.t6 VDD.t199 VDD.t198 pfet_03v3 ad=3.52p pd=16.88u as=2.08p ps=8.52u w=8u l=0.28u
X222 VDD.t147 CLKP_HB.t9 a_2700_6400.t2 VDD.t146 pfet_03v3 ad=2.08p pd=8.52u as=2.08p ps=8.52u w=8u l=0.28u
X223 a_14220_6400.t8 a_6924_6400.t6 VSS.t41 VSS.t40 nfet_03v3 ad=2.08p pd=8.52u as=2.08p ps=8.52u w=8u l=0.28u
X224 VDD.t123 a_6924_6400.t17 a_14220_6400.t12 VDD.t122 pfet_03v3 ad=2.08p pd=8.52u as=2.08p ps=8.52u w=8u l=0.28u
X225 VDD.t179 a_6924_41600.t17 a_14220_41600.t15 VDD.t178 pfet_03v3 ad=2.08p pd=8.52u as=2.08p ps=8.52u w=8u l=0.28u
X226 VDD.t135 CLKP_H.t7 a_4812_6400.t0 VDD.t134 pfet_03v3 ad=2.08p pd=8.52u as=3.52p ps=16.88u w=8u l=0.28u
X227 O_CAPTURE_CLKB.t0 a_2700_41600.t20 VDD.t27 VDD.t26 pfet_03v3 ad=2.08p pd=8.52u as=2.08p ps=8.52u w=8u l=0.28u
X228 VDD.t133 CLKP_H.t5 a_4812_6400.t2 VDD.t132 pfet_03v3 ad=2.08p pd=8.52u as=2.08p ps=8.52u w=8u l=0.28u
X229 VDD.t61 a_4812_41600.t23 O_CAPTURE_CLK.t1 VDD.t60 pfet_03v3 ad=2.08p pd=8.52u as=3.52p ps=16.88u w=8u l=0.28u
X230 VDD.t101 a_14220_41600.t37 O_SENSE.t21 VDD.t100 pfet_03v3 ad=2.08p pd=8.52u as=2.08p ps=8.52u w=8u l=0.28u
X231 VDD.t113 a_14220_6400.t63 E_SENSE.t19 VDD.t112 pfet_03v3 ad=2.08p pd=8.52u as=3.52p ps=16.88u w=8u l=0.28u
R0 E_SENSE.n46 E_SENSE.n30 12.2879
R1 E_SENSE.n46 E_SENSE.n45 9.1267
R2 E_SENSE.n32 E_SENSE.t10 5.7796
R3 E_SENSE.n1 E_SENSE.t24 5.73764
R4 E_SENSE.n45 E_SENSE.t47 5.59012
R5 E_SENSE.n30 E_SENSE.t19 5.54817
R6 E_SENSE.n32 E_SENSE.n31 5.38537
R7 E_SENSE.n34 E_SENSE.n33 5.38537
R8 E_SENSE.n36 E_SENSE.n35 5.38537
R9 E_SENSE.n38 E_SENSE.n37 5.38537
R10 E_SENSE.n40 E_SENSE.n39 5.38537
R11 E_SENSE.n42 E_SENSE.n41 5.38537
R12 E_SENSE.n44 E_SENSE.n43 5.38537
R13 E_SENSE.n1 E_SENSE.n0 5.32067
R14 E_SENSE.n3 E_SENSE.n2 5.32067
R15 E_SENSE.n5 E_SENSE.n4 5.32067
R16 E_SENSE.n7 E_SENSE.n6 5.32067
R17 E_SENSE.n9 E_SENSE.n8 5.32067
R18 E_SENSE.n11 E_SENSE.n10 5.32067
R19 E_SENSE.n13 E_SENSE.n12 5.32067
R20 E_SENSE.n15 E_SENSE.n14 5.32067
R21 E_SENSE.n17 E_SENSE.n16 5.32067
R22 E_SENSE.n19 E_SENSE.n18 5.32067
R23 E_SENSE.n21 E_SENSE.n20 5.32067
R24 E_SENSE.n23 E_SENSE.n22 5.32067
R25 E_SENSE.n25 E_SENSE.n24 5.32067
R26 E_SENSE.n27 E_SENSE.n26 5.32067
R27 E_SENSE.n29 E_SENSE.n28 5.32067
R28 E_SENSE E_SENSE.n46 4.61985
R29 E_SENSE.n0 E_SENSE.t34 0.228
R30 E_SENSE.n0 E_SENSE.t25 0.228
R31 E_SENSE.n2 E_SENSE.t30 0.228
R32 E_SENSE.n2 E_SENSE.t35 0.228
R33 E_SENSE.n4 E_SENSE.t42 0.228
R34 E_SENSE.n4 E_SENSE.t31 0.228
R35 E_SENSE.n6 E_SENSE.t28 0.228
R36 E_SENSE.n6 E_SENSE.t43 0.228
R37 E_SENSE.n8 E_SENSE.t26 0.228
R38 E_SENSE.n8 E_SENSE.t29 0.228
R39 E_SENSE.n10 E_SENSE.t22 0.228
R40 E_SENSE.n10 E_SENSE.t27 0.228
R41 E_SENSE.n12 E_SENSE.t8 0.228
R42 E_SENSE.n12 E_SENSE.t23 0.228
R43 E_SENSE.n14 E_SENSE.t2 0.228
R44 E_SENSE.n14 E_SENSE.t9 0.228
R45 E_SENSE.n16 E_SENSE.t14 0.228
R46 E_SENSE.n16 E_SENSE.t3 0.228
R47 E_SENSE.n18 E_SENSE.t40 0.228
R48 E_SENSE.n18 E_SENSE.t15 0.228
R49 E_SENSE.n20 E_SENSE.t20 0.228
R50 E_SENSE.n20 E_SENSE.t41 0.228
R51 E_SENSE.n22 E_SENSE.t6 0.228
R52 E_SENSE.n22 E_SENSE.t21 0.228
R53 E_SENSE.n24 E_SENSE.t0 0.228
R54 E_SENSE.n24 E_SENSE.t7 0.228
R55 E_SENSE.n26 E_SENSE.t12 0.228
R56 E_SENSE.n26 E_SENSE.t1 0.228
R57 E_SENSE.n28 E_SENSE.t18 0.228
R58 E_SENSE.n28 E_SENSE.t13 0.228
R59 E_SENSE.n31 E_SENSE.t36 0.20525
R60 E_SENSE.n31 E_SENSE.t11 0.20525
R61 E_SENSE.n33 E_SENSE.t4 0.20525
R62 E_SENSE.n33 E_SENSE.t37 0.20525
R63 E_SENSE.n35 E_SENSE.t16 0.20525
R64 E_SENSE.n35 E_SENSE.t5 0.20525
R65 E_SENSE.n37 E_SENSE.t32 0.20525
R66 E_SENSE.n37 E_SENSE.t17 0.20525
R67 E_SENSE.n39 E_SENSE.t44 0.20525
R68 E_SENSE.n39 E_SENSE.t33 0.20525
R69 E_SENSE.n41 E_SENSE.t38 0.20525
R70 E_SENSE.n41 E_SENSE.t45 0.20525
R71 E_SENSE.n43 E_SENSE.t46 0.20525
R72 E_SENSE.n43 E_SENSE.t39 0.20525
R73 E_SENSE.n30 E_SENSE.n29 0.189974
R74 E_SENSE.n29 E_SENSE.n27 0.189974
R75 E_SENSE.n27 E_SENSE.n25 0.189974
R76 E_SENSE.n25 E_SENSE.n23 0.189974
R77 E_SENSE.n23 E_SENSE.n21 0.189974
R78 E_SENSE.n21 E_SENSE.n19 0.189974
R79 E_SENSE.n19 E_SENSE.n17 0.189974
R80 E_SENSE.n17 E_SENSE.n15 0.189974
R81 E_SENSE.n15 E_SENSE.n13 0.189974
R82 E_SENSE.n13 E_SENSE.n11 0.189974
R83 E_SENSE.n11 E_SENSE.n9 0.189974
R84 E_SENSE.n9 E_SENSE.n7 0.189974
R85 E_SENSE.n7 E_SENSE.n5 0.189974
R86 E_SENSE.n5 E_SENSE.n3 0.189974
R87 E_SENSE.n3 E_SENSE.n1 0.189974
R88 E_SENSE.n45 E_SENSE.n44 0.189974
R89 E_SENSE.n44 E_SENSE.n42 0.189974
R90 E_SENSE.n42 E_SENSE.n40 0.189974
R91 E_SENSE.n40 E_SENSE.n38 0.189974
R92 E_SENSE.n38 E_SENSE.n36 0.189974
R93 E_SENSE.n36 E_SENSE.n34 0.189974
R94 E_SENSE.n34 E_SENSE.n32 0.189974
R95 E_CAPTURE_CLK E_CAPTURE_CLK.n14 7.98157
R96 E_CAPTURE_CLK.n14 E_CAPTURE_CLK.n6 6.5392
R97 E_CAPTURE_CLK.n8 E_CAPTURE_CLK.t11 5.7796
R98 E_CAPTURE_CLK.n1 E_CAPTURE_CLK.t13 5.73764
R99 E_CAPTURE_CLK.n13 E_CAPTURE_CLK.t12 5.59012
R100 E_CAPTURE_CLK.n6 E_CAPTURE_CLK.t0 5.54817
R101 E_CAPTURE_CLK.n8 E_CAPTURE_CLK.n7 5.38537
R102 E_CAPTURE_CLK.n10 E_CAPTURE_CLK.n9 5.38537
R103 E_CAPTURE_CLK.n12 E_CAPTURE_CLK.n11 5.38537
R104 E_CAPTURE_CLK.n1 E_CAPTURE_CLK.n0 5.32067
R105 E_CAPTURE_CLK.n3 E_CAPTURE_CLK.n2 5.32067
R106 E_CAPTURE_CLK.n5 E_CAPTURE_CLK.n4 5.32067
R107 E_CAPTURE_CLK.n14 E_CAPTURE_CLK.n13 4.61063
R108 E_CAPTURE_CLK.n0 E_CAPTURE_CLK.t10 0.228
R109 E_CAPTURE_CLK.n0 E_CAPTURE_CLK.t9 0.228
R110 E_CAPTURE_CLK.n2 E_CAPTURE_CLK.t8 0.228
R111 E_CAPTURE_CLK.n2 E_CAPTURE_CLK.t7 0.228
R112 E_CAPTURE_CLK.n4 E_CAPTURE_CLK.t4 0.228
R113 E_CAPTURE_CLK.n4 E_CAPTURE_CLK.t3 0.228
R114 E_CAPTURE_CLK.n7 E_CAPTURE_CLK.t15 0.20525
R115 E_CAPTURE_CLK.n7 E_CAPTURE_CLK.t14 0.20525
R116 E_CAPTURE_CLK.n9 E_CAPTURE_CLK.t6 0.20525
R117 E_CAPTURE_CLK.n9 E_CAPTURE_CLK.t5 0.20525
R118 E_CAPTURE_CLK.n11 E_CAPTURE_CLK.t2 0.20525
R119 E_CAPTURE_CLK.n11 E_CAPTURE_CLK.t1 0.20525
R120 E_CAPTURE_CLK.n13 E_CAPTURE_CLK.n12 0.189974
R121 E_CAPTURE_CLK.n12 E_CAPTURE_CLK.n10 0.189974
R122 E_CAPTURE_CLK.n10 E_CAPTURE_CLK.n8 0.189974
R123 E_CAPTURE_CLK.n6 E_CAPTURE_CLK.n5 0.189974
R124 E_CAPTURE_CLK.n5 E_CAPTURE_CLK.n3 0.189974
R125 E_CAPTURE_CLK.n3 E_CAPTURE_CLK.n1 0.189974
R126 E_CAPTURE_CLKB E_CAPTURE_CLKB.n14 6.63157
R127 E_CAPTURE_CLKB.n14 E_CAPTURE_CLKB.n6 6.5392
R128 E_CAPTURE_CLKB.n8 E_CAPTURE_CLKB.t13 5.7796
R129 E_CAPTURE_CLKB.n1 E_CAPTURE_CLKB.t5 5.73764
R130 E_CAPTURE_CLKB.n13 E_CAPTURE_CLKB.t1 5.59012
R131 E_CAPTURE_CLKB.n6 E_CAPTURE_CLKB.t9 5.54817
R132 E_CAPTURE_CLKB.n8 E_CAPTURE_CLKB.n7 5.38537
R133 E_CAPTURE_CLKB.n10 E_CAPTURE_CLKB.n9 5.38537
R134 E_CAPTURE_CLKB.n12 E_CAPTURE_CLKB.n11 5.38537
R135 E_CAPTURE_CLKB.n1 E_CAPTURE_CLKB.n0 5.32067
R136 E_CAPTURE_CLKB.n3 E_CAPTURE_CLKB.n2 5.32067
R137 E_CAPTURE_CLKB.n5 E_CAPTURE_CLKB.n4 5.32067
R138 E_CAPTURE_CLKB.n14 E_CAPTURE_CLKB.n13 4.61063
R139 E_CAPTURE_CLKB.n0 E_CAPTURE_CLKB.t12 0.228
R140 E_CAPTURE_CLKB.n0 E_CAPTURE_CLKB.t0 0.228
R141 E_CAPTURE_CLKB.n2 E_CAPTURE_CLKB.t14 0.228
R142 E_CAPTURE_CLKB.n2 E_CAPTURE_CLKB.t3 0.228
R143 E_CAPTURE_CLKB.n4 E_CAPTURE_CLKB.t6 0.228
R144 E_CAPTURE_CLKB.n4 E_CAPTURE_CLKB.t2 0.228
R145 E_CAPTURE_CLKB.n7 E_CAPTURE_CLKB.t4 0.20525
R146 E_CAPTURE_CLKB.n7 E_CAPTURE_CLKB.t15 0.20525
R147 E_CAPTURE_CLKB.n9 E_CAPTURE_CLKB.t10 0.20525
R148 E_CAPTURE_CLKB.n9 E_CAPTURE_CLKB.t11 0.20525
R149 E_CAPTURE_CLKB.n11 E_CAPTURE_CLKB.t7 0.20525
R150 E_CAPTURE_CLKB.n11 E_CAPTURE_CLKB.t8 0.20525
R151 E_CAPTURE_CLKB.n13 E_CAPTURE_CLKB.n12 0.189974
R152 E_CAPTURE_CLKB.n12 E_CAPTURE_CLKB.n10 0.189974
R153 E_CAPTURE_CLKB.n10 E_CAPTURE_CLKB.n8 0.189974
R154 E_CAPTURE_CLKB.n6 E_CAPTURE_CLKB.n5 0.189974
R155 E_CAPTURE_CLKB.n5 E_CAPTURE_CLKB.n3 0.189974
R156 E_CAPTURE_CLKB.n3 E_CAPTURE_CLKB.n1 0.189974
R157 CLKP_H.n8 CLKP_H.t3 113.632
R158 CLKP_H.n5 CLKP_H.t0 113.632
R159 CLKP_H.n0 CLKP_H.t4 113.632
R160 CLKP_H.n3 CLKP_H.t7 113.632
R161 CLKP_H.n6 CLKP_H.t1 109.174
R162 CLKP_H.n7 CLKP_H.t2 109.174
R163 CLKP_H.n1 CLKP_H.t5 109.174
R164 CLKP_H.n2 CLKP_H.t6 109.174
R165 CLKP_H CLKP_H.n10 15.3874
R166 CLKP_H.n7 CLKP_H.n6 11.6805
R167 CLKP_H.n2 CLKP_H.n1 11.6805
R168 CLKP_H.n10 CLKP_H.n4 10.9291
R169 CLKP_H.n10 CLKP_H.n9 9.0005
R170 CLKP_H.n9 CLKP_H.n5 7.10487
R171 CLKP_H.n9 CLKP_H.n8 7.10487
R172 CLKP_H.n4 CLKP_H.n0 7.10487
R173 CLKP_H.n4 CLKP_H.n3 7.10487
R174 CLKP_H.n6 CLKP_H.n5 4.42851
R175 CLKP_H.n8 CLKP_H.n7 4.42851
R176 CLKP_H.n1 CLKP_H.n0 4.42851
R177 CLKP_H.n3 CLKP_H.n2 4.42851
R178 CLKP_HB.n11 CLKP_HB.t5 113.632
R179 CLKP_HB.n8 CLKP_HB.t2 113.632
R180 CLKP_HB.n3 CLKP_HB.t8 113.632
R181 CLKP_HB.n6 CLKP_HB.t11 113.632
R182 CLKP_HB.n1 CLKP_HB.t0 113.618
R183 CLKP_HB.n1 CLKP_HB.t1 113.618
R184 CLKP_HB.n0 CLKP_HB.t6 113.618
R185 CLKP_HB.n0 CLKP_HB.t7 113.618
R186 CLKP_HB.n9 CLKP_HB.t3 109.174
R187 CLKP_HB.n10 CLKP_HB.t4 109.174
R188 CLKP_HB.n4 CLKP_HB.t9 109.174
R189 CLKP_HB.n5 CLKP_HB.t10 109.174
R190 CLKP_HB.n2 CLKP_HB.n0 17.9899
R191 CLKP_HB.n2 CLKP_HB.n1 16.0613
R192 CLKP_HB.n10 CLKP_HB.n9 11.6805
R193 CLKP_HB.n5 CLKP_HB.n4 11.6805
R194 CLKP_HB.n13 CLKP_HB.n7 10.9291
R195 CLKP_HB.n13 CLKP_HB.n12 9.0005
R196 CLKP_HB.n14 CLKP_HB.n2 8.55302
R197 CLKP_HB CLKP_HB.n14 8.25354
R198 CLKP_HB.n12 CLKP_HB.n8 7.10487
R199 CLKP_HB.n12 CLKP_HB.n11 7.10487
R200 CLKP_HB.n7 CLKP_HB.n3 7.10487
R201 CLKP_HB.n7 CLKP_HB.n6 7.10487
R202 CLKP_HB.n14 CLKP_HB.n13 4.59693
R203 CLKP_HB.n9 CLKP_HB.n8 4.42851
R204 CLKP_HB.n11 CLKP_HB.n10 4.42851
R205 CLKP_HB.n4 CLKP_HB.n3 4.42851
R206 CLKP_HB.n6 CLKP_HB.n5 4.42851
R207 O_SENSE.n46 O_SENSE.n30 12.2879
R208 O_SENSE.n46 O_SENSE.n45 9.1267
R209 O_SENSE.n32 O_SENSE.t10 5.7796
R210 O_SENSE.n1 O_SENSE.t8 5.73764
R211 O_SENSE.n45 O_SENSE.t27 5.59012
R212 O_SENSE.n30 O_SENSE.t33 5.54817
R213 O_SENSE.n32 O_SENSE.n31 5.38537
R214 O_SENSE.n34 O_SENSE.n33 5.38537
R215 O_SENSE.n36 O_SENSE.n35 5.38537
R216 O_SENSE.n38 O_SENSE.n37 5.38537
R217 O_SENSE.n40 O_SENSE.n39 5.38537
R218 O_SENSE.n42 O_SENSE.n41 5.38537
R219 O_SENSE.n44 O_SENSE.n43 5.38537
R220 O_SENSE.n1 O_SENSE.n0 5.32067
R221 O_SENSE.n3 O_SENSE.n2 5.32067
R222 O_SENSE.n5 O_SENSE.n4 5.32067
R223 O_SENSE.n7 O_SENSE.n6 5.32067
R224 O_SENSE.n9 O_SENSE.n8 5.32067
R225 O_SENSE.n11 O_SENSE.n10 5.32067
R226 O_SENSE.n13 O_SENSE.n12 5.32067
R227 O_SENSE.n15 O_SENSE.n14 5.32067
R228 O_SENSE.n17 O_SENSE.n16 5.32067
R229 O_SENSE.n19 O_SENSE.n18 5.32067
R230 O_SENSE.n21 O_SENSE.n20 5.32067
R231 O_SENSE.n23 O_SENSE.n22 5.32067
R232 O_SENSE.n25 O_SENSE.n24 5.32067
R233 O_SENSE.n27 O_SENSE.n26 5.32067
R234 O_SENSE.n29 O_SENSE.n28 5.32067
R235 O_SENSE O_SENSE.n46 4.61985
R236 O_SENSE.n0 O_SENSE.t14 0.228
R237 O_SENSE.n0 O_SENSE.t9 0.228
R238 O_SENSE.n2 O_SENSE.t20 0.228
R239 O_SENSE.n2 O_SENSE.t15 0.228
R240 O_SENSE.n4 O_SENSE.t2 0.228
R241 O_SENSE.n4 O_SENSE.t21 0.228
R242 O_SENSE.n6 O_SENSE.t24 0.228
R243 O_SENSE.n6 O_SENSE.t3 0.228
R244 O_SENSE.n8 O_SENSE.t6 0.228
R245 O_SENSE.n8 O_SENSE.t25 0.228
R246 O_SENSE.n10 O_SENSE.t12 0.228
R247 O_SENSE.n10 O_SENSE.t7 0.228
R248 O_SENSE.n12 O_SENSE.t18 0.228
R249 O_SENSE.n12 O_SENSE.t13 0.228
R250 O_SENSE.n14 O_SENSE.t0 0.228
R251 O_SENSE.n14 O_SENSE.t19 0.228
R252 O_SENSE.n16 O_SENSE.t38 0.228
R253 O_SENSE.n16 O_SENSE.t1 0.228
R254 O_SENSE.n18 O_SENSE.t36 0.228
R255 O_SENSE.n18 O_SENSE.t39 0.228
R256 O_SENSE.n20 O_SENSE.t46 0.228
R257 O_SENSE.n20 O_SENSE.t37 0.228
R258 O_SENSE.n22 O_SENSE.t44 0.228
R259 O_SENSE.n22 O_SENSE.t47 0.228
R260 O_SENSE.n24 O_SENSE.t34 0.228
R261 O_SENSE.n24 O_SENSE.t45 0.228
R262 O_SENSE.n26 O_SENSE.t42 0.228
R263 O_SENSE.n26 O_SENSE.t35 0.228
R264 O_SENSE.n28 O_SENSE.t32 0.228
R265 O_SENSE.n28 O_SENSE.t43 0.228
R266 O_SENSE.n31 O_SENSE.t16 0.20525
R267 O_SENSE.n31 O_SENSE.t11 0.20525
R268 O_SENSE.n33 O_SENSE.t22 0.20525
R269 O_SENSE.n33 O_SENSE.t17 0.20525
R270 O_SENSE.n35 O_SENSE.t30 0.20525
R271 O_SENSE.n35 O_SENSE.t23 0.20525
R272 O_SENSE.n37 O_SENSE.t4 0.20525
R273 O_SENSE.n37 O_SENSE.t31 0.20525
R274 O_SENSE.n39 O_SENSE.t28 0.20525
R275 O_SENSE.n39 O_SENSE.t5 0.20525
R276 O_SENSE.n41 O_SENSE.t40 0.20525
R277 O_SENSE.n41 O_SENSE.t29 0.20525
R278 O_SENSE.n43 O_SENSE.t26 0.20525
R279 O_SENSE.n43 O_SENSE.t41 0.20525
R280 O_SENSE.n30 O_SENSE.n29 0.189974
R281 O_SENSE.n29 O_SENSE.n27 0.189974
R282 O_SENSE.n27 O_SENSE.n25 0.189974
R283 O_SENSE.n25 O_SENSE.n23 0.189974
R284 O_SENSE.n23 O_SENSE.n21 0.189974
R285 O_SENSE.n21 O_SENSE.n19 0.189974
R286 O_SENSE.n19 O_SENSE.n17 0.189974
R287 O_SENSE.n17 O_SENSE.n15 0.189974
R288 O_SENSE.n15 O_SENSE.n13 0.189974
R289 O_SENSE.n13 O_SENSE.n11 0.189974
R290 O_SENSE.n11 O_SENSE.n9 0.189974
R291 O_SENSE.n9 O_SENSE.n7 0.189974
R292 O_SENSE.n7 O_SENSE.n5 0.189974
R293 O_SENSE.n5 O_SENSE.n3 0.189974
R294 O_SENSE.n3 O_SENSE.n1 0.189974
R295 O_SENSE.n45 O_SENSE.n44 0.189974
R296 O_SENSE.n44 O_SENSE.n42 0.189974
R297 O_SENSE.n42 O_SENSE.n40 0.189974
R298 O_SENSE.n40 O_SENSE.n38 0.189974
R299 O_SENSE.n38 O_SENSE.n36 0.189974
R300 O_SENSE.n36 O_SENSE.n34 0.189974
R301 O_SENSE.n34 O_SENSE.n32 0.189974
R302 O_CAPTURE_CLK O_CAPTURE_CLK.n14 7.98157
R303 O_CAPTURE_CLK.n14 O_CAPTURE_CLK.n6 6.5392
R304 O_CAPTURE_CLK.n8 O_CAPTURE_CLK.t4 5.7796
R305 O_CAPTURE_CLK.n1 O_CAPTURE_CLK.t12 5.73764
R306 O_CAPTURE_CLK.n13 O_CAPTURE_CLK.t15 5.59012
R307 O_CAPTURE_CLK.n6 O_CAPTURE_CLK.t1 5.54817
R308 O_CAPTURE_CLK.n8 O_CAPTURE_CLK.n7 5.38537
R309 O_CAPTURE_CLK.n10 O_CAPTURE_CLK.n9 5.38537
R310 O_CAPTURE_CLK.n12 O_CAPTURE_CLK.n11 5.38537
R311 O_CAPTURE_CLK.n1 O_CAPTURE_CLK.n0 5.32067
R312 O_CAPTURE_CLK.n3 O_CAPTURE_CLK.n2 5.32067
R313 O_CAPTURE_CLK.n5 O_CAPTURE_CLK.n4 5.32067
R314 O_CAPTURE_CLK.n14 O_CAPTURE_CLK.n13 4.61063
R315 O_CAPTURE_CLK.n0 O_CAPTURE_CLK.t10 0.228
R316 O_CAPTURE_CLK.n0 O_CAPTURE_CLK.t13 0.228
R317 O_CAPTURE_CLK.n2 O_CAPTURE_CLK.t6 0.228
R318 O_CAPTURE_CLK.n2 O_CAPTURE_CLK.t11 0.228
R319 O_CAPTURE_CLK.n4 O_CAPTURE_CLK.t0 0.228
R320 O_CAPTURE_CLK.n4 O_CAPTURE_CLK.t7 0.228
R321 O_CAPTURE_CLK.n7 O_CAPTURE_CLK.t8 0.20525
R322 O_CAPTURE_CLK.n7 O_CAPTURE_CLK.t5 0.20525
R323 O_CAPTURE_CLK.n9 O_CAPTURE_CLK.t2 0.20525
R324 O_CAPTURE_CLK.n9 O_CAPTURE_CLK.t9 0.20525
R325 O_CAPTURE_CLK.n11 O_CAPTURE_CLK.t14 0.20525
R326 O_CAPTURE_CLK.n11 O_CAPTURE_CLK.t3 0.20525
R327 O_CAPTURE_CLK.n13 O_CAPTURE_CLK.n12 0.189974
R328 O_CAPTURE_CLK.n12 O_CAPTURE_CLK.n10 0.189974
R329 O_CAPTURE_CLK.n10 O_CAPTURE_CLK.n8 0.189974
R330 O_CAPTURE_CLK.n6 O_CAPTURE_CLK.n5 0.189974
R331 O_CAPTURE_CLK.n5 O_CAPTURE_CLK.n3 0.189974
R332 O_CAPTURE_CLK.n3 O_CAPTURE_CLK.n1 0.189974
R333 O_CAPTURE_CLKB O_CAPTURE_CLKB.n14 6.63157
R334 O_CAPTURE_CLKB.n14 O_CAPTURE_CLKB.n6 6.5392
R335 O_CAPTURE_CLKB.n8 O_CAPTURE_CLKB.t6 5.7796
R336 O_CAPTURE_CLKB.n1 O_CAPTURE_CLKB.t7 5.73764
R337 O_CAPTURE_CLKB.n13 O_CAPTURE_CLKB.t5 5.59012
R338 O_CAPTURE_CLKB.n6 O_CAPTURE_CLKB.t3 5.54817
R339 O_CAPTURE_CLKB.n8 O_CAPTURE_CLKB.n7 5.38537
R340 O_CAPTURE_CLKB.n10 O_CAPTURE_CLKB.n9 5.38537
R341 O_CAPTURE_CLKB.n12 O_CAPTURE_CLKB.n11 5.38537
R342 O_CAPTURE_CLKB.n1 O_CAPTURE_CLKB.n0 5.32067
R343 O_CAPTURE_CLKB.n3 O_CAPTURE_CLKB.n2 5.32067
R344 O_CAPTURE_CLKB.n5 O_CAPTURE_CLKB.n4 5.32067
R345 O_CAPTURE_CLKB.n14 O_CAPTURE_CLKB.n13 4.61063
R346 O_CAPTURE_CLKB.n0 O_CAPTURE_CLKB.t9 0.228
R347 O_CAPTURE_CLKB.n0 O_CAPTURE_CLKB.t8 0.228
R348 O_CAPTURE_CLKB.n2 O_CAPTURE_CLKB.t0 0.228
R349 O_CAPTURE_CLKB.n2 O_CAPTURE_CLKB.t10 0.228
R350 O_CAPTURE_CLKB.n4 O_CAPTURE_CLKB.t2 0.228
R351 O_CAPTURE_CLKB.n4 O_CAPTURE_CLKB.t1 0.228
R352 O_CAPTURE_CLKB.n7 O_CAPTURE_CLKB.t13 0.20525
R353 O_CAPTURE_CLKB.n7 O_CAPTURE_CLKB.t15 0.20525
R354 O_CAPTURE_CLKB.n9 O_CAPTURE_CLKB.t11 0.20525
R355 O_CAPTURE_CLKB.n9 O_CAPTURE_CLKB.t14 0.20525
R356 O_CAPTURE_CLKB.n11 O_CAPTURE_CLKB.t4 0.20525
R357 O_CAPTURE_CLKB.n11 O_CAPTURE_CLKB.t12 0.20525
R358 O_CAPTURE_CLKB.n13 O_CAPTURE_CLKB.n12 0.189974
R359 O_CAPTURE_CLKB.n12 O_CAPTURE_CLKB.n10 0.189974
R360 O_CAPTURE_CLKB.n10 O_CAPTURE_CLKB.n8 0.189974
R361 O_CAPTURE_CLKB.n6 O_CAPTURE_CLKB.n5 0.189974
R362 O_CAPTURE_CLKB.n5 O_CAPTURE_CLKB.n3 0.189974
R363 O_CAPTURE_CLKB.n3 O_CAPTURE_CLKB.n1 0.189974
R364 CLKN_H.n8 CLKN_H.t3 113.632
R365 CLKN_H.n5 CLKN_H.t0 113.632
R366 CLKN_H.n0 CLKN_H.t4 113.632
R367 CLKN_H.n3 CLKN_H.t7 113.632
R368 CLKN_H.n6 CLKN_H.t1 109.174
R369 CLKN_H.n7 CLKN_H.t2 109.174
R370 CLKN_H.n1 CLKN_H.t5 109.174
R371 CLKN_H.n2 CLKN_H.t6 109.174
R372 CLKN_H CLKN_H.n10 15.3874
R373 CLKN_H.n7 CLKN_H.n6 11.6805
R374 CLKN_H.n2 CLKN_H.n1 11.6805
R375 CLKN_H.n10 CLKN_H.n4 10.9291
R376 CLKN_H.n10 CLKN_H.n9 9.0005
R377 CLKN_H.n9 CLKN_H.n5 7.10487
R378 CLKN_H.n9 CLKN_H.n8 7.10487
R379 CLKN_H.n4 CLKN_H.n0 7.10487
R380 CLKN_H.n4 CLKN_H.n3 7.10487
R381 CLKN_H.n6 CLKN_H.n5 4.42851
R382 CLKN_H.n8 CLKN_H.n7 4.42851
R383 CLKN_H.n1 CLKN_H.n0 4.42851
R384 CLKN_H.n3 CLKN_H.n2 4.42851
R385 CLKN_HB.n11 CLKN_HB.t5 113.632
R386 CLKN_HB.n8 CLKN_HB.t2 113.632
R387 CLKN_HB.n3 CLKN_HB.t8 113.632
R388 CLKN_HB.n6 CLKN_HB.t11 113.632
R389 CLKN_HB.n1 CLKN_HB.t0 113.618
R390 CLKN_HB.n1 CLKN_HB.t1 113.618
R391 CLKN_HB.n0 CLKN_HB.t6 113.618
R392 CLKN_HB.n0 CLKN_HB.t7 113.618
R393 CLKN_HB.n9 CLKN_HB.t3 109.174
R394 CLKN_HB.n10 CLKN_HB.t4 109.174
R395 CLKN_HB.n4 CLKN_HB.t9 109.174
R396 CLKN_HB.n5 CLKN_HB.t10 109.174
R397 CLKN_HB.n2 CLKN_HB.n0 17.9899
R398 CLKN_HB.n2 CLKN_HB.n1 16.0613
R399 CLKN_HB.n10 CLKN_HB.n9 11.6805
R400 CLKN_HB.n5 CLKN_HB.n4 11.6805
R401 CLKN_HB.n13 CLKN_HB.n7 10.9291
R402 CLKN_HB CLKN_HB.n14 9.03615
R403 CLKN_HB.n13 CLKN_HB.n12 9.0005
R404 CLKN_HB.n14 CLKN_HB.n2 8.55302
R405 CLKN_HB.n12 CLKN_HB.n8 7.10487
R406 CLKN_HB.n12 CLKN_HB.n11 7.10487
R407 CLKN_HB.n7 CLKN_HB.n3 7.10487
R408 CLKN_HB.n7 CLKN_HB.n6 7.10487
R409 CLKN_HB.n14 CLKN_HB.n13 4.59693
R410 CLKN_HB.n9 CLKN_HB.n8 4.42851
R411 CLKN_HB.n11 CLKN_HB.n10 4.42851
R412 CLKN_HB.n4 CLKN_HB.n3 4.42851
R413 CLKN_HB.n6 CLKN_HB.n5 4.42851
R414 VDD.n74 VDD.t48 510.404
R415 VDD.n2 VDD.t154 510.404
R416 VDD.t238 VDD.t202 450.829
R417 VDD.t206 VDD.t236 450.829
R418 VDD.t64 VDD.t198 450.829
R419 VDD.t60 VDD.t90 450.829
R420 VDD.t56 VDD.t218 450.829
R421 VDD.t216 VDD.t80 450.829
R422 VDD.t134 VDD.t150 450.829
R423 VDD.t148 VDD.t136 450.829
R424 VDD.t188 VDD.t152 450.829
R425 VDD.t42 VDD.t102 450.829
R426 VDD.t38 VDD.t234 450.829
R427 VDD.t112 VDD.t40 450.829
R428 VDD.t204 VDD.n73 417.582
R429 VDD.t142 VDD.n1 417.582
R430 VDD.t200 VDD.t204 44.1994
R431 VDD.t208 VDD.t200 44.1994
R432 VDD.t202 VDD.t208 44.1994
R433 VDD.t242 VDD.t238 44.1994
R434 VDD.t240 VDD.t242 44.1994
R435 VDD.t236 VDD.t240 44.1994
R436 VDD.t198 VDD.t206 44.1994
R437 VDD.t62 VDD.t64 44.1994
R438 VDD.t28 VDD.t62 44.1994
R439 VDD.t26 VDD.t28 44.1994
R440 VDD.t108 VDD.t26 44.1994
R441 VDD.t106 VDD.t108 44.1994
R442 VDD.t92 VDD.t106 44.1994
R443 VDD.t90 VDD.t92 44.1994
R444 VDD.t58 VDD.t60 44.1994
R445 VDD.t140 VDD.t58 44.1994
R446 VDD.t138 VDD.t140 44.1994
R447 VDD.t212 VDD.t138 44.1994
R448 VDD.t210 VDD.t212 44.1994
R449 VDD.t220 VDD.t210 44.1994
R450 VDD.t218 VDD.t220 44.1994
R451 VDD.t54 VDD.t56 44.1994
R452 VDD.t178 VDD.t54 44.1994
R453 VDD.t176 VDD.t178 44.1994
R454 VDD.t24 VDD.t176 44.1994
R455 VDD.t22 VDD.t24 44.1994
R456 VDD.t104 VDD.t22 44.1994
R457 VDD.t80 VDD.t104 44.1994
R458 VDD.t214 VDD.t216 44.1994
R459 VDD.t254 VDD.t214 44.1994
R460 VDD.t252 VDD.t254 44.1994
R461 VDD.t224 VDD.t252 44.1994
R462 VDD.t222 VDD.t224 44.1994
R463 VDD.t258 VDD.t222 44.1994
R464 VDD.t256 VDD.t258 44.1994
R465 VDD.t262 VDD.t256 44.1994
R466 VDD.t260 VDD.t262 44.1994
R467 VDD.t228 VDD.t260 44.1994
R468 VDD.t226 VDD.t228 44.1994
R469 VDD.t232 VDD.t226 44.1994
R470 VDD.t230 VDD.t232 44.1994
R471 VDD.t14 VDD.t230 44.1994
R472 VDD.t12 VDD.t14 44.1994
R473 VDD.t96 VDD.t12 44.1994
R474 VDD.t94 VDD.t96 44.1994
R475 VDD.t84 VDD.t94 44.1994
R476 VDD.t82 VDD.t84 44.1994
R477 VDD.t46 VDD.t82 44.1994
R478 VDD.t44 VDD.t46 44.1994
R479 VDD.t170 VDD.t44 44.1994
R480 VDD.t168 VDD.t170 44.1994
R481 VDD.t18 VDD.t168 44.1994
R482 VDD.t16 VDD.t18 44.1994
R483 VDD.t100 VDD.t16 44.1994
R484 VDD.t98 VDD.t100 44.1994
R485 VDD.t88 VDD.t98 44.1994
R486 VDD.t86 VDD.t88 44.1994
R487 VDD.t50 VDD.t86 44.1994
R488 VDD.t48 VDD.t50 44.1994
R489 VDD.t144 VDD.t142 44.1994
R490 VDD.t146 VDD.t144 44.1994
R491 VDD.t150 VDD.t146 44.1994
R492 VDD.t130 VDD.t134 44.1994
R493 VDD.t132 VDD.t130 44.1994
R494 VDD.t136 VDD.t132 44.1994
R495 VDD.t152 VDD.t148 44.1994
R496 VDD.t162 VDD.t188 44.1994
R497 VDD.t52 VDD.t162 44.1994
R498 VDD.t250 VDD.t52 44.1994
R499 VDD.t78 VDD.t250 44.1994
R500 VDD.t244 VDD.t78 44.1994
R501 VDD.t20 VDD.t244 44.1994
R502 VDD.t102 VDD.t20 44.1994
R503 VDD.t128 VDD.t42 44.1994
R504 VDD.t126 VDD.t128 44.1994
R505 VDD.t160 VDD.t126 44.1994
R506 VDD.t158 VDD.t160 44.1994
R507 VDD.t192 VDD.t158 44.1994
R508 VDD.t190 VDD.t192 44.1994
R509 VDD.t234 VDD.t190 44.1994
R510 VDD.t124 VDD.t38 44.1994
R511 VDD.t122 VDD.t124 44.1994
R512 VDD.t76 VDD.t122 44.1994
R513 VDD.t74 VDD.t76 44.1994
R514 VDD.t10 VDD.t74 44.1994
R515 VDD.t8 VDD.t10 44.1994
R516 VDD.t40 VDD.t8 44.1994
R517 VDD.t110 VDD.t112 44.1994
R518 VDD.t68 VDD.t110 44.1994
R519 VDD.t66 VDD.t68 44.1994
R520 VDD.t2 VDD.t66 44.1994
R521 VDD.t0 VDD.t2 44.1994
R522 VDD.t32 VDD.t0 44.1994
R523 VDD.t30 VDD.t32 44.1994
R524 VDD.t116 VDD.t30 44.1994
R525 VDD.t114 VDD.t116 44.1994
R526 VDD.t196 VDD.t114 44.1994
R527 VDD.t194 VDD.t196 44.1994
R528 VDD.t72 VDD.t194 44.1994
R529 VDD.t70 VDD.t72 44.1994
R530 VDD.t6 VDD.t70 44.1994
R531 VDD.t4 VDD.t6 44.1994
R532 VDD.t36 VDD.t4 44.1994
R533 VDD.t34 VDD.t36 44.1994
R534 VDD.t120 VDD.t34 44.1994
R535 VDD.t118 VDD.t120 44.1994
R536 VDD.t166 VDD.t118 44.1994
R537 VDD.t164 VDD.t166 44.1994
R538 VDD.t174 VDD.t164 44.1994
R539 VDD.t172 VDD.t174 44.1994
R540 VDD.t248 VDD.t172 44.1994
R541 VDD.t246 VDD.t248 44.1994
R542 VDD.t182 VDD.t246 44.1994
R543 VDD.t180 VDD.t182 44.1994
R544 VDD.t186 VDD.t180 44.1994
R545 VDD.t184 VDD.t186 44.1994
R546 VDD.t156 VDD.t184 44.1994
R547 VDD.t154 VDD.t156 44.1994
R548 VDD.n132 VDD.n131 16.4863
R549 VDD.n60 VDD.n59 16.4863
R550 VDD.n106 VDD.n105 11.1661
R551 VDD.n114 VDD.n113 11.1661
R552 VDD.n122 VDD.n121 11.1661
R553 VDD.n130 VDD.n129 11.1661
R554 VDD.n136 VDD.n135 11.1661
R555 VDD.n140 VDD.n139 11.1661
R556 VDD.n34 VDD.n33 11.1661
R557 VDD.n42 VDD.n41 11.1661
R558 VDD.n50 VDD.n49 11.1661
R559 VDD.n58 VDD.n57 11.1661
R560 VDD.n64 VDD.n63 11.1661
R561 VDD.n68 VDD.n67 11.1661
R562 VDD.n77 VDD.n75 5.51014
R563 VDD.n109 VDD.n107 5.51014
R564 VDD.n117 VDD.n115 5.51014
R565 VDD.n125 VDD.n123 5.51014
R566 VDD.n135 VDD.n133 5.51014
R567 VDD.n139 VDD.n137 5.51014
R568 VDD.n5 VDD.n3 5.51014
R569 VDD.n37 VDD.n35 5.51014
R570 VDD.n45 VDD.n43 5.51014
R571 VDD.n53 VDD.n51 5.51014
R572 VDD.n63 VDD.n61 5.51014
R573 VDD.n67 VDD.n65 5.51014
R574 VDD.n105 VDD.n104 5.32067
R575 VDD.n103 VDD.n102 5.32067
R576 VDD.n101 VDD.n100 5.32067
R577 VDD.n99 VDD.n98 5.32067
R578 VDD.n97 VDD.n96 5.32067
R579 VDD.n95 VDD.n94 5.32067
R580 VDD.n93 VDD.n92 5.32067
R581 VDD.n91 VDD.n90 5.32067
R582 VDD.n89 VDD.n88 5.32067
R583 VDD.n87 VDD.n86 5.32067
R584 VDD.n85 VDD.n84 5.32067
R585 VDD.n83 VDD.n82 5.32067
R586 VDD.n81 VDD.n80 5.32067
R587 VDD.n79 VDD.n78 5.32067
R588 VDD.n77 VDD.n76 5.32067
R589 VDD.n113 VDD.n112 5.32067
R590 VDD.n111 VDD.n110 5.32067
R591 VDD.n109 VDD.n108 5.32067
R592 VDD.n121 VDD.n120 5.32067
R593 VDD.n119 VDD.n118 5.32067
R594 VDD.n117 VDD.n116 5.32067
R595 VDD.n129 VDD.n128 5.32067
R596 VDD.n127 VDD.n126 5.32067
R597 VDD.n125 VDD.n124 5.32067
R598 VDD.n135 VDD.n134 5.32067
R599 VDD.n139 VDD.n138 5.32067
R600 VDD.n33 VDD.n32 5.32067
R601 VDD.n31 VDD.n30 5.32067
R602 VDD.n29 VDD.n28 5.32067
R603 VDD.n27 VDD.n26 5.32067
R604 VDD.n25 VDD.n24 5.32067
R605 VDD.n23 VDD.n22 5.32067
R606 VDD.n21 VDD.n20 5.32067
R607 VDD.n19 VDD.n18 5.32067
R608 VDD.n17 VDD.n16 5.32067
R609 VDD.n15 VDD.n14 5.32067
R610 VDD.n13 VDD.n12 5.32067
R611 VDD.n11 VDD.n10 5.32067
R612 VDD.n9 VDD.n8 5.32067
R613 VDD.n7 VDD.n6 5.32067
R614 VDD.n5 VDD.n4 5.32067
R615 VDD.n41 VDD.n40 5.32067
R616 VDD.n39 VDD.n38 5.32067
R617 VDD.n37 VDD.n36 5.32067
R618 VDD.n49 VDD.n48 5.32067
R619 VDD.n47 VDD.n46 5.32067
R620 VDD.n45 VDD.n44 5.32067
R621 VDD.n57 VDD.n56 5.32067
R622 VDD.n55 VDD.n54 5.32067
R623 VDD.n53 VDD.n52 5.32067
R624 VDD.n63 VDD.n62 5.32067
R625 VDD.n67 VDD.n66 5.32067
R626 VDD.n72 VDD.n0 4.5005
R627 VDD.n144 VDD.n0 4.5005
R628 VDD.n72 VDD.n71 3.31026
R629 VDD.n144 VDD.n143 2.76928
R630 VDD.n146 VDD.n145 2.26839
R631 VDD.n143 VDD.n142 2.2545
R632 VDD.n71 VDD.n70 2.2545
R633 VDD.n142 VDD.n141 2.2505
R634 VDD.n70 VDD.n69 2.2505
R635 VDD.n142 VDD.n74 1.86985
R636 VDD.n70 VDD.n2 1.86985
R637 VDD VDD.n146 1.13544
R638 VDD.n114 VDD.n106 0.7421
R639 VDD.n42 VDD.n34 0.7421
R640 VDD.n132 VDD.n130 0.3101
R641 VDD.n130 VDD.n122 0.3101
R642 VDD.n122 VDD.n114 0.3101
R643 VDD.n60 VDD.n58 0.3101
R644 VDD.n58 VDD.n50 0.3101
R645 VDD.n50 VDD.n42 0.3101
R646 VDD.n140 VDD.n136 0.2381
R647 VDD.n68 VDD.n64 0.2381
R648 VDD.n141 VDD.n140 0.236975
R649 VDD.n69 VDD.n68 0.236975
R650 VDD.n104 VDD.t51 0.228
R651 VDD.n104 VDD.t49 0.228
R652 VDD.n102 VDD.t89 0.228
R653 VDD.n102 VDD.t87 0.228
R654 VDD.n100 VDD.t101 0.228
R655 VDD.n100 VDD.t99 0.228
R656 VDD.n98 VDD.t19 0.228
R657 VDD.n98 VDD.t17 0.228
R658 VDD.n96 VDD.t171 0.228
R659 VDD.n96 VDD.t169 0.228
R660 VDD.n94 VDD.t47 0.228
R661 VDD.n94 VDD.t45 0.228
R662 VDD.n92 VDD.t85 0.228
R663 VDD.n92 VDD.t83 0.228
R664 VDD.n90 VDD.t97 0.228
R665 VDD.n90 VDD.t95 0.228
R666 VDD.n88 VDD.t15 0.228
R667 VDD.n88 VDD.t13 0.228
R668 VDD.n86 VDD.t233 0.228
R669 VDD.n86 VDD.t231 0.228
R670 VDD.n84 VDD.t229 0.228
R671 VDD.n84 VDD.t227 0.228
R672 VDD.n82 VDD.t263 0.228
R673 VDD.n82 VDD.t261 0.228
R674 VDD.n80 VDD.t259 0.228
R675 VDD.n80 VDD.t257 0.228
R676 VDD.n78 VDD.t225 0.228
R677 VDD.n78 VDD.t223 0.228
R678 VDD.n76 VDD.t255 0.228
R679 VDD.n76 VDD.t253 0.228
R680 VDD.n75 VDD.t217 0.228
R681 VDD.n75 VDD.t215 0.228
R682 VDD.n112 VDD.t105 0.228
R683 VDD.n112 VDD.t81 0.228
R684 VDD.n110 VDD.t25 0.228
R685 VDD.n110 VDD.t23 0.228
R686 VDD.n108 VDD.t179 0.228
R687 VDD.n108 VDD.t177 0.228
R688 VDD.n107 VDD.t57 0.228
R689 VDD.n107 VDD.t55 0.228
R690 VDD.n120 VDD.t221 0.228
R691 VDD.n120 VDD.t219 0.228
R692 VDD.n118 VDD.t213 0.228
R693 VDD.n118 VDD.t211 0.228
R694 VDD.n116 VDD.t141 0.228
R695 VDD.n116 VDD.t139 0.228
R696 VDD.n115 VDD.t61 0.228
R697 VDD.n115 VDD.t59 0.228
R698 VDD.n128 VDD.t93 0.228
R699 VDD.n128 VDD.t91 0.228
R700 VDD.n126 VDD.t109 0.228
R701 VDD.n126 VDD.t107 0.228
R702 VDD.n124 VDD.t29 0.228
R703 VDD.n124 VDD.t27 0.228
R704 VDD.n123 VDD.t65 0.228
R705 VDD.n123 VDD.t63 0.228
R706 VDD.n131 VDD.t207 0.228
R707 VDD.n131 VDD.t199 0.228
R708 VDD.n134 VDD.t241 0.228
R709 VDD.n134 VDD.t237 0.228
R710 VDD.n133 VDD.t239 0.228
R711 VDD.n133 VDD.t243 0.228
R712 VDD.n138 VDD.t209 0.228
R713 VDD.n138 VDD.t203 0.228
R714 VDD.n137 VDD.t205 0.228
R715 VDD.n137 VDD.t201 0.228
R716 VDD.n32 VDD.t157 0.228
R717 VDD.n32 VDD.t155 0.228
R718 VDD.n30 VDD.t187 0.228
R719 VDD.n30 VDD.t185 0.228
R720 VDD.n28 VDD.t183 0.228
R721 VDD.n28 VDD.t181 0.228
R722 VDD.n26 VDD.t249 0.228
R723 VDD.n26 VDD.t247 0.228
R724 VDD.n24 VDD.t175 0.228
R725 VDD.n24 VDD.t173 0.228
R726 VDD.n22 VDD.t167 0.228
R727 VDD.n22 VDD.t165 0.228
R728 VDD.n20 VDD.t121 0.228
R729 VDD.n20 VDD.t119 0.228
R730 VDD.n18 VDD.t37 0.228
R731 VDD.n18 VDD.t35 0.228
R732 VDD.n16 VDD.t7 0.228
R733 VDD.n16 VDD.t5 0.228
R734 VDD.n14 VDD.t73 0.228
R735 VDD.n14 VDD.t71 0.228
R736 VDD.n12 VDD.t197 0.228
R737 VDD.n12 VDD.t195 0.228
R738 VDD.n10 VDD.t117 0.228
R739 VDD.n10 VDD.t115 0.228
R740 VDD.n8 VDD.t33 0.228
R741 VDD.n8 VDD.t31 0.228
R742 VDD.n6 VDD.t3 0.228
R743 VDD.n6 VDD.t1 0.228
R744 VDD.n4 VDD.t69 0.228
R745 VDD.n4 VDD.t67 0.228
R746 VDD.n3 VDD.t113 0.228
R747 VDD.n3 VDD.t111 0.228
R748 VDD.n40 VDD.t9 0.228
R749 VDD.n40 VDD.t41 0.228
R750 VDD.n38 VDD.t75 0.228
R751 VDD.n38 VDD.t11 0.228
R752 VDD.n36 VDD.t123 0.228
R753 VDD.n36 VDD.t77 0.228
R754 VDD.n35 VDD.t39 0.228
R755 VDD.n35 VDD.t125 0.228
R756 VDD.n48 VDD.t191 0.228
R757 VDD.n48 VDD.t235 0.228
R758 VDD.n46 VDD.t159 0.228
R759 VDD.n46 VDD.t193 0.228
R760 VDD.n44 VDD.t127 0.228
R761 VDD.n44 VDD.t161 0.228
R762 VDD.n43 VDD.t43 0.228
R763 VDD.n43 VDD.t129 0.228
R764 VDD.n56 VDD.t21 0.228
R765 VDD.n56 VDD.t103 0.228
R766 VDD.n54 VDD.t79 0.228
R767 VDD.n54 VDD.t245 0.228
R768 VDD.n52 VDD.t53 0.228
R769 VDD.n52 VDD.t251 0.228
R770 VDD.n51 VDD.t189 0.228
R771 VDD.n51 VDD.t163 0.228
R772 VDD.n59 VDD.t149 0.228
R773 VDD.n59 VDD.t153 0.228
R774 VDD.n62 VDD.t133 0.228
R775 VDD.n62 VDD.t137 0.228
R776 VDD.n61 VDD.t135 0.228
R777 VDD.n61 VDD.t131 0.228
R778 VDD.n66 VDD.t147 0.228
R779 VDD.n66 VDD.t151 0.228
R780 VDD.n65 VDD.t143 0.228
R781 VDD.n65 VDD.t145 0.228
R782 VDD.n136 VDD.n132 0.2021
R783 VDD.n64 VDD.n60 0.2021
R784 VDD.n79 VDD.n77 0.189974
R785 VDD.n81 VDD.n79 0.189974
R786 VDD.n83 VDD.n81 0.189974
R787 VDD.n85 VDD.n83 0.189974
R788 VDD.n87 VDD.n85 0.189974
R789 VDD.n89 VDD.n87 0.189974
R790 VDD.n91 VDD.n89 0.189974
R791 VDD.n93 VDD.n91 0.189974
R792 VDD.n95 VDD.n93 0.189974
R793 VDD.n97 VDD.n95 0.189974
R794 VDD.n99 VDD.n97 0.189974
R795 VDD.n101 VDD.n99 0.189974
R796 VDD.n103 VDD.n101 0.189974
R797 VDD.n105 VDD.n103 0.189974
R798 VDD.n111 VDD.n109 0.189974
R799 VDD.n113 VDD.n111 0.189974
R800 VDD.n119 VDD.n117 0.189974
R801 VDD.n121 VDD.n119 0.189974
R802 VDD.n127 VDD.n125 0.189974
R803 VDD.n129 VDD.n127 0.189974
R804 VDD.n7 VDD.n5 0.189974
R805 VDD.n9 VDD.n7 0.189974
R806 VDD.n11 VDD.n9 0.189974
R807 VDD.n13 VDD.n11 0.189974
R808 VDD.n15 VDD.n13 0.189974
R809 VDD.n17 VDD.n15 0.189974
R810 VDD.n19 VDD.n17 0.189974
R811 VDD.n21 VDD.n19 0.189974
R812 VDD.n23 VDD.n21 0.189974
R813 VDD.n25 VDD.n23 0.189974
R814 VDD.n27 VDD.n25 0.189974
R815 VDD.n29 VDD.n27 0.189974
R816 VDD.n31 VDD.n29 0.189974
R817 VDD.n33 VDD.n31 0.189974
R818 VDD.n39 VDD.n37 0.189974
R819 VDD.n41 VDD.n39 0.189974
R820 VDD.n47 VDD.n45 0.189974
R821 VDD.n49 VDD.n47 0.189974
R822 VDD.n55 VDD.n53 0.189974
R823 VDD.n57 VDD.n55 0.189974
R824 VDD.n106 VDD.n74 0.165161
R825 VDD.n34 VDD.n2 0.165161
R826 VDD.n146 VDD.n0 0.020105
R827 VDD.n143 VDD.n73 0.00725
R828 VDD.n141 VDD.n73 0.00725
R829 VDD.n71 VDD.n1 0.00725
R830 VDD.n69 VDD.n1 0.00725
R831 VDD.n145 VDD.n144 0.0054955
R832 VDD.n145 VDD.n72 0.0054955
R833 VSS.n64 VSS.n63 5121.21
R834 VSS.n121 VSS.n64 5121.21
R835 VSS.n61 VSS.n60 4481.39
R836 VSS.n122 VSS.n121 4318.81
R837 VSS.n62 VSS.n61 3545.45
R838 VSS.n63 VSS.n62 3545.45
R839 VSS.n6 VSS.t8 2776.74
R840 VSS.n116 VSS.t20 2776.74
R841 VSS.t196 VSS.t46 2643.58
R842 VSS.t118 VSS.t26 2643.58
R843 VSS.t76 VSS.t96 1481.56
R844 VSS.t94 VSS.t82 1481.56
R845 VSS.t24 VSS.t90 1481.56
R846 VSS.t168 VSS.t192 1481.56
R847 VSS.t14 VSS.t160 1481.56
R848 VSS.t170 VSS.t156 1481.56
R849 VSS.t148 VSS.t176 1481.56
R850 VSS.t34 VSS.t158 1481.56
R851 VSS.t164 VSS.t54 1481.56
R852 VSS.t112 VSS.t50 1481.56
R853 VSS.t92 VSS.n4 1285.47
R854 VSS.n120 VSS.t150 1285.47
R855 VSS.n62 VSS.n3 933.923
R856 VSS.n63 VSS.n2 933.923
R857 VSS.n61 VSS.n4 907.822
R858 VSS.n121 VSS.n120 907.822
R859 VSS.n123 VSS.n64 351.702
R860 VSS.t98 VSS.t92 145.251
R861 VSS.t100 VSS.t98 145.251
R862 VSS.t96 VSS.t100 145.251
R863 VSS.t78 VSS.t76 145.251
R864 VSS.t80 VSS.t78 145.251
R865 VSS.t82 VSS.t80 145.251
R866 VSS.t90 VSS.t94 145.251
R867 VSS.t128 VSS.t24 145.251
R868 VSS.t138 VSS.t128 145.251
R869 VSS.t144 VSS.t138 145.251
R870 VSS.t178 VSS.t144 145.251
R871 VSS.t64 VSS.t178 145.251
R872 VSS.t198 VSS.t64 145.251
R873 VSS.t192 VSS.t198 145.251
R874 VSS.t18 VSS.t168 145.251
R875 VSS.t16 VSS.t18 145.251
R876 VSS.t74 VSS.t16 145.251
R877 VSS.t72 VSS.t74 145.251
R878 VSS.t186 VSS.t72 145.251
R879 VSS.t184 VSS.t186 145.251
R880 VSS.t160 VSS.t184 145.251
R881 VSS.t70 VSS.t14 145.251
R882 VSS.t44 VSS.t70 145.251
R883 VSS.t42 VSS.t44 145.251
R884 VSS.t146 VSS.t42 145.251
R885 VSS.t40 VSS.t146 145.251
R886 VSS.t12 VSS.t40 145.251
R887 VSS.t46 VSS.t12 145.251
R888 VSS.t194 VSS.t196 145.251
R889 VSS.t142 VSS.t194 145.251
R890 VSS.t140 VSS.t142 145.251
R891 VSS.t182 VSS.t140 145.251
R892 VSS.t180 VSS.t182 145.251
R893 VSS.t122 VSS.t180 145.251
R894 VSS.t120 VSS.t122 145.251
R895 VSS.t38 VSS.t120 145.251
R896 VSS.t36 VSS.t38 145.251
R897 VSS.t2 VSS.t36 145.251
R898 VSS.t0 VSS.t2 145.251
R899 VSS.t132 VSS.t0 145.251
R900 VSS.t130 VSS.t132 145.251
R901 VSS.t10 VSS.t130 145.251
R902 VSS.t8 VSS.t10 145.251
R903 VSS.t152 VSS.t150 145.251
R904 VSS.t154 VSS.t152 145.251
R905 VSS.t156 VSS.t154 145.251
R906 VSS.t174 VSS.t170 145.251
R907 VSS.t172 VSS.t174 145.251
R908 VSS.t176 VSS.t172 145.251
R909 VSS.t158 VSS.t148 145.251
R910 VSS.t32 VSS.t34 145.251
R911 VSS.t104 VSS.t32 145.251
R912 VSS.t102 VSS.t104 145.251
R913 VSS.t110 VSS.t102 145.251
R914 VSS.t108 VSS.t110 145.251
R915 VSS.t166 VSS.t108 145.251
R916 VSS.t54 VSS.t166 145.251
R917 VSS.t162 VSS.t164 145.251
R918 VSS.t30 VSS.t162 145.251
R919 VSS.t28 VSS.t30 145.251
R920 VSS.t86 VSS.t28 145.251
R921 VSS.t84 VSS.t86 145.251
R922 VSS.t52 VSS.t84 145.251
R923 VSS.t50 VSS.t52 145.251
R924 VSS.t48 VSS.t112 145.251
R925 VSS.t106 VSS.t48 145.251
R926 VSS.t114 VSS.t106 145.251
R927 VSS.t88 VSS.t114 145.251
R928 VSS.t68 VSS.t88 145.251
R929 VSS.t66 VSS.t68 145.251
R930 VSS.t26 VSS.t66 145.251
R931 VSS.t116 VSS.t118 145.251
R932 VSS.t190 VSS.t116 145.251
R933 VSS.t188 VSS.t190 145.251
R934 VSS.t126 VSS.t188 145.251
R935 VSS.t124 VSS.t126 145.251
R936 VSS.t6 VSS.t124 145.251
R937 VSS.t4 VSS.t6 145.251
R938 VSS.t136 VSS.t4 145.251
R939 VSS.t134 VSS.t136 145.251
R940 VSS.t62 VSS.t134 145.251
R941 VSS.t60 VSS.t62 145.251
R942 VSS.t58 VSS.t60 145.251
R943 VSS.t56 VSS.t58 145.251
R944 VSS.t22 VSS.t56 145.251
R945 VSS.t20 VSS.t22 145.251
R946 VSS.n5 VSS.n4 24.2219
R947 VSS.n120 VSS.n119 24.2219
R948 VSS.n48 VSS.n47 15.3617
R949 VSS.n75 VSS.n74 15.3617
R950 VSS.n22 VSS.n21 9.9768
R951 VSS.n30 VSS.n29 9.9768
R952 VSS.n38 VSS.n37 9.9768
R953 VSS.n46 VSS.n45 9.9768
R954 VSS.n52 VSS.n51 9.9768
R955 VSS.n56 VSS.n55 9.9768
R956 VSS.n115 VSS.n114 9.9768
R957 VSS.n99 VSS.n98 9.9768
R958 VSS.n91 VSS.n90 9.9768
R959 VSS.n83 VSS.n82 9.9768
R960 VSS.n73 VSS.n72 9.9768
R961 VSS.n69 VSS.n68 9.9768
R962 VSS.n9 VSS.n7 5.57485
R963 VSS.n25 VSS.n23 5.57485
R964 VSS.n33 VSS.n31 5.57485
R965 VSS.n41 VSS.n39 5.57485
R966 VSS.n51 VSS.n49 5.57485
R967 VSS.n55 VSS.n53 5.57485
R968 VSS.n102 VSS.n100 5.57485
R969 VSS.n94 VSS.n92 5.57485
R970 VSS.n86 VSS.n84 5.57485
R971 VSS.n78 VSS.n76 5.57485
R972 VSS.n72 VSS.n70 5.57485
R973 VSS.n68 VSS.n66 5.57485
R974 VSS.n21 VSS.n20 5.38537
R975 VSS.n19 VSS.n18 5.38537
R976 VSS.n17 VSS.n16 5.38537
R977 VSS.n15 VSS.n14 5.38537
R978 VSS.n13 VSS.n12 5.38537
R979 VSS.n11 VSS.n10 5.38537
R980 VSS.n9 VSS.n8 5.38537
R981 VSS.n29 VSS.n28 5.38537
R982 VSS.n27 VSS.n26 5.38537
R983 VSS.n25 VSS.n24 5.38537
R984 VSS.n37 VSS.n36 5.38537
R985 VSS.n35 VSS.n34 5.38537
R986 VSS.n33 VSS.n32 5.38537
R987 VSS.n45 VSS.n44 5.38537
R988 VSS.n43 VSS.n42 5.38537
R989 VSS.n41 VSS.n40 5.38537
R990 VSS.n51 VSS.n50 5.38537
R991 VSS.n55 VSS.n54 5.38537
R992 VSS.n114 VSS.n113 5.38537
R993 VSS.n112 VSS.n111 5.38537
R994 VSS.n110 VSS.n109 5.38537
R995 VSS.n108 VSS.n107 5.38537
R996 VSS.n106 VSS.n105 5.38537
R997 VSS.n104 VSS.n103 5.38537
R998 VSS.n102 VSS.n101 5.38537
R999 VSS.n98 VSS.n97 5.38537
R1000 VSS.n96 VSS.n95 5.38537
R1001 VSS.n94 VSS.n93 5.38537
R1002 VSS.n90 VSS.n89 5.38537
R1003 VSS.n88 VSS.n87 5.38537
R1004 VSS.n86 VSS.n85 5.38537
R1005 VSS.n82 VSS.n81 5.38537
R1006 VSS.n80 VSS.n79 5.38537
R1007 VSS.n78 VSS.n77 5.38537
R1008 VSS.n72 VSS.n71 5.38537
R1009 VSS.n68 VSS.n67 5.38537
R1010 VSS.n1 VSS.n0 4.5005
R1011 VSS.n124 VSS.n0 4.5005
R1012 VSS.n126 VSS.n125 2.26839
R1013 VSS.n59 VSS.n58 2.2545
R1014 VSS.n117 VSS.n65 2.2545
R1015 VSS.n58 VSS.n57 2.2505
R1016 VSS.n118 VSS.n117 2.2505
R1017 VSS.n60 VSS.n59 1.90124
R1018 VSS.n122 VSS.n65 1.90124
R1019 VSS.n58 VSS.n6 1.86985
R1020 VSS.n117 VSS.n116 1.86985
R1021 VSS VSS.n126 1.13544
R1022 VSS.n30 VSS.n22 0.5981
R1023 VSS.n115 VSS.n99 0.5981
R1024 VSS.n60 VSS.n3 0.543479
R1025 VSS.n3 VSS.n2 0.543479
R1026 VSS.n123 VSS.n122 0.543479
R1027 VSS.n2 VSS.n1 0.507615
R1028 VSS.n124 VSS.n123 0.507363
R1029 VSS.n48 VSS.n46 0.3101
R1030 VSS.n46 VSS.n38 0.3101
R1031 VSS.n38 VSS.n30 0.3101
R1032 VSS.n83 VSS.n75 0.3101
R1033 VSS.n91 VSS.n83 0.3101
R1034 VSS.n99 VSS.n91 0.3101
R1035 VSS.n22 VSS.n6 0.309161
R1036 VSS.n116 VSS.n115 0.309161
R1037 VSS.n56 VSS.n52 0.2381
R1038 VSS.n73 VSS.n69 0.2381
R1039 VSS.n57 VSS.n56 0.236975
R1040 VSS.n118 VSS.n69 0.236975
R1041 VSS.n20 VSS.t11 0.20525
R1042 VSS.n20 VSS.t9 0.20525
R1043 VSS.n18 VSS.t133 0.20525
R1044 VSS.n18 VSS.t131 0.20525
R1045 VSS.n16 VSS.t3 0.20525
R1046 VSS.n16 VSS.t1 0.20525
R1047 VSS.n14 VSS.t39 0.20525
R1048 VSS.n14 VSS.t37 0.20525
R1049 VSS.n12 VSS.t123 0.20525
R1050 VSS.n12 VSS.t121 0.20525
R1051 VSS.n10 VSS.t183 0.20525
R1052 VSS.n10 VSS.t181 0.20525
R1053 VSS.n8 VSS.t143 0.20525
R1054 VSS.n8 VSS.t141 0.20525
R1055 VSS.n7 VSS.t197 0.20525
R1056 VSS.n7 VSS.t195 0.20525
R1057 VSS.n28 VSS.t13 0.20525
R1058 VSS.n28 VSS.t47 0.20525
R1059 VSS.n26 VSS.t147 0.20525
R1060 VSS.n26 VSS.t41 0.20525
R1061 VSS.n24 VSS.t45 0.20525
R1062 VSS.n24 VSS.t43 0.20525
R1063 VSS.n23 VSS.t15 0.20525
R1064 VSS.n23 VSS.t71 0.20525
R1065 VSS.n36 VSS.t185 0.20525
R1066 VSS.n36 VSS.t161 0.20525
R1067 VSS.n34 VSS.t73 0.20525
R1068 VSS.n34 VSS.t187 0.20525
R1069 VSS.n32 VSS.t17 0.20525
R1070 VSS.n32 VSS.t75 0.20525
R1071 VSS.n31 VSS.t169 0.20525
R1072 VSS.n31 VSS.t19 0.20525
R1073 VSS.n44 VSS.t199 0.20525
R1074 VSS.n44 VSS.t193 0.20525
R1075 VSS.n42 VSS.t179 0.20525
R1076 VSS.n42 VSS.t65 0.20525
R1077 VSS.n40 VSS.t139 0.20525
R1078 VSS.n40 VSS.t145 0.20525
R1079 VSS.n39 VSS.t25 0.20525
R1080 VSS.n39 VSS.t129 0.20525
R1081 VSS.n47 VSS.t95 0.20525
R1082 VSS.n47 VSS.t91 0.20525
R1083 VSS.n50 VSS.t81 0.20525
R1084 VSS.n50 VSS.t83 0.20525
R1085 VSS.n49 VSS.t77 0.20525
R1086 VSS.n49 VSS.t79 0.20525
R1087 VSS.n54 VSS.t101 0.20525
R1088 VSS.n54 VSS.t97 0.20525
R1089 VSS.n53 VSS.t93 0.20525
R1090 VSS.n53 VSS.t99 0.20525
R1091 VSS.n113 VSS.t23 0.20525
R1092 VSS.n113 VSS.t21 0.20525
R1093 VSS.n111 VSS.t59 0.20525
R1094 VSS.n111 VSS.t57 0.20525
R1095 VSS.n109 VSS.t63 0.20525
R1096 VSS.n109 VSS.t61 0.20525
R1097 VSS.n107 VSS.t137 0.20525
R1098 VSS.n107 VSS.t135 0.20525
R1099 VSS.n105 VSS.t7 0.20525
R1100 VSS.n105 VSS.t5 0.20525
R1101 VSS.n103 VSS.t127 0.20525
R1102 VSS.n103 VSS.t125 0.20525
R1103 VSS.n101 VSS.t191 0.20525
R1104 VSS.n101 VSS.t189 0.20525
R1105 VSS.n100 VSS.t119 0.20525
R1106 VSS.n100 VSS.t117 0.20525
R1107 VSS.n97 VSS.t67 0.20525
R1108 VSS.n97 VSS.t27 0.20525
R1109 VSS.n95 VSS.t89 0.20525
R1110 VSS.n95 VSS.t69 0.20525
R1111 VSS.n93 VSS.t107 0.20525
R1112 VSS.n93 VSS.t115 0.20525
R1113 VSS.n92 VSS.t113 0.20525
R1114 VSS.n92 VSS.t49 0.20525
R1115 VSS.n89 VSS.t53 0.20525
R1116 VSS.n89 VSS.t51 0.20525
R1117 VSS.n87 VSS.t87 0.20525
R1118 VSS.n87 VSS.t85 0.20525
R1119 VSS.n85 VSS.t31 0.20525
R1120 VSS.n85 VSS.t29 0.20525
R1121 VSS.n84 VSS.t165 0.20525
R1122 VSS.n84 VSS.t163 0.20525
R1123 VSS.n81 VSS.t167 0.20525
R1124 VSS.n81 VSS.t55 0.20525
R1125 VSS.n79 VSS.t111 0.20525
R1126 VSS.n79 VSS.t109 0.20525
R1127 VSS.n77 VSS.t105 0.20525
R1128 VSS.n77 VSS.t103 0.20525
R1129 VSS.n76 VSS.t35 0.20525
R1130 VSS.n76 VSS.t33 0.20525
R1131 VSS.n74 VSS.t149 0.20525
R1132 VSS.n74 VSS.t159 0.20525
R1133 VSS.n71 VSS.t173 0.20525
R1134 VSS.n71 VSS.t177 0.20525
R1135 VSS.n70 VSS.t171 0.20525
R1136 VSS.n70 VSS.t175 0.20525
R1137 VSS.n67 VSS.t155 0.20525
R1138 VSS.n67 VSS.t157 0.20525
R1139 VSS.n66 VSS.t151 0.20525
R1140 VSS.n66 VSS.t153 0.20525
R1141 VSS.n52 VSS.n48 0.2021
R1142 VSS.n75 VSS.n73 0.2021
R1143 VSS.n11 VSS.n9 0.189974
R1144 VSS.n13 VSS.n11 0.189974
R1145 VSS.n15 VSS.n13 0.189974
R1146 VSS.n17 VSS.n15 0.189974
R1147 VSS.n19 VSS.n17 0.189974
R1148 VSS.n21 VSS.n19 0.189974
R1149 VSS.n27 VSS.n25 0.189974
R1150 VSS.n29 VSS.n27 0.189974
R1151 VSS.n35 VSS.n33 0.189974
R1152 VSS.n37 VSS.n35 0.189974
R1153 VSS.n43 VSS.n41 0.189974
R1154 VSS.n45 VSS.n43 0.189974
R1155 VSS.n104 VSS.n102 0.189974
R1156 VSS.n106 VSS.n104 0.189974
R1157 VSS.n108 VSS.n106 0.189974
R1158 VSS.n110 VSS.n108 0.189974
R1159 VSS.n112 VSS.n110 0.189974
R1160 VSS.n114 VSS.n112 0.189974
R1161 VSS.n96 VSS.n94 0.189974
R1162 VSS.n98 VSS.n96 0.189974
R1163 VSS.n88 VSS.n86 0.189974
R1164 VSS.n90 VSS.n88 0.189974
R1165 VSS.n80 VSS.n78 0.189974
R1166 VSS.n82 VSS.n80 0.189974
R1167 VSS.n126 VSS.n0 0.020105
R1168 VSS.n59 VSS.n5 0.00725
R1169 VSS.n57 VSS.n5 0.00725
R1170 VSS.n119 VSS.n65 0.00725
R1171 VSS.n119 VSS.n118 0.00725
R1172 VSS.n125 VSS.n124 0.0054955
R1173 VSS.n125 VSS.n1 0.0054955
R1174 a_14220_6400.n67 a_14220_6400.t31 113.632
R1175 a_14220_6400.n77 a_14220_6400.t16 113.632
R1176 a_14220_6400.n14 a_14220_6400.t63 113.632
R1177 a_14220_6400.n36 a_14220_6400.t32 113.632
R1178 a_14220_6400.n86 a_14220_6400.t23 109.174
R1179 a_14220_6400.n87 a_14220_6400.t24 109.174
R1180 a_14220_6400.n68 a_14220_6400.t30 109.174
R1181 a_14220_6400.n69 a_14220_6400.t29 109.174
R1182 a_14220_6400.n70 a_14220_6400.t28 109.174
R1183 a_14220_6400.n71 a_14220_6400.t27 109.174
R1184 a_14220_6400.n72 a_14220_6400.t26 109.174
R1185 a_14220_6400.n73 a_14220_6400.t25 109.174
R1186 a_14220_6400.n85 a_14220_6400.t22 109.174
R1187 a_14220_6400.n74 a_14220_6400.t21 109.174
R1188 a_14220_6400.n81 a_14220_6400.t20 109.174
R1189 a_14220_6400.n80 a_14220_6400.t19 109.174
R1190 a_14220_6400.n79 a_14220_6400.t18 109.174
R1191 a_14220_6400.n76 a_14220_6400.t17 109.174
R1192 a_14220_6400.n57 a_14220_6400.t47 109.174
R1193 a_14220_6400.n58 a_14220_6400.t48 109.174
R1194 a_14220_6400.n15 a_14220_6400.t62 109.174
R1195 a_14220_6400.n16 a_14220_6400.t61 109.174
R1196 a_14220_6400.n17 a_14220_6400.t60 109.174
R1197 a_14220_6400.n18 a_14220_6400.t59 109.174
R1198 a_14220_6400.n19 a_14220_6400.t58 109.174
R1199 a_14220_6400.n20 a_14220_6400.t57 109.174
R1200 a_14220_6400.n21 a_14220_6400.t56 109.174
R1201 a_14220_6400.n22 a_14220_6400.t55 109.174
R1202 a_14220_6400.n23 a_14220_6400.t54 109.174
R1203 a_14220_6400.n24 a_14220_6400.t53 109.174
R1204 a_14220_6400.n25 a_14220_6400.t52 109.174
R1205 a_14220_6400.n26 a_14220_6400.t51 109.174
R1206 a_14220_6400.n27 a_14220_6400.t50 109.174
R1207 a_14220_6400.n28 a_14220_6400.t49 109.174
R1208 a_14220_6400.n56 a_14220_6400.t46 109.174
R1209 a_14220_6400.n29 a_14220_6400.t45 109.174
R1210 a_14220_6400.n52 a_14220_6400.t44 109.174
R1211 a_14220_6400.n51 a_14220_6400.t43 109.174
R1212 a_14220_6400.n50 a_14220_6400.t42 109.174
R1213 a_14220_6400.n31 a_14220_6400.t41 109.174
R1214 a_14220_6400.n46 a_14220_6400.t40 109.174
R1215 a_14220_6400.n45 a_14220_6400.t39 109.174
R1216 a_14220_6400.n44 a_14220_6400.t38 109.174
R1217 a_14220_6400.n33 a_14220_6400.t37 109.174
R1218 a_14220_6400.n40 a_14220_6400.t36 109.174
R1219 a_14220_6400.n39 a_14220_6400.t35 109.174
R1220 a_14220_6400.n38 a_14220_6400.t34 109.174
R1221 a_14220_6400.n35 a_14220_6400.t33 109.174
R1222 a_14220_6400.n86 a_14220_6400.n61 18.4942
R1223 a_14220_6400.n88 a_14220_6400.n87 18.4942
R1224 a_14220_6400.n69 a_14220_6400.n66 18.4942
R1225 a_14220_6400.n70 a_14220_6400.n65 18.4942
R1226 a_14220_6400.n71 a_14220_6400.n64 18.4942
R1227 a_14220_6400.n72 a_14220_6400.n63 18.4942
R1228 a_14220_6400.n73 a_14220_6400.n62 18.4942
R1229 a_14220_6400.n85 a_14220_6400.n84 18.4942
R1230 a_14220_6400.n83 a_14220_6400.n74 18.4942
R1231 a_14220_6400.n82 a_14220_6400.n81 18.4942
R1232 a_14220_6400.n80 a_14220_6400.n75 18.4942
R1233 a_14220_6400.n79 a_14220_6400.n78 18.4942
R1234 a_14220_6400.n57 a_14220_6400.n0 18.4942
R1235 a_14220_6400.n59 a_14220_6400.n58 18.4942
R1236 a_14220_6400.n16 a_14220_6400.n13 18.4942
R1237 a_14220_6400.n17 a_14220_6400.n12 18.4942
R1238 a_14220_6400.n18 a_14220_6400.n11 18.4942
R1239 a_14220_6400.n19 a_14220_6400.n10 18.4942
R1240 a_14220_6400.n20 a_14220_6400.n9 18.4942
R1241 a_14220_6400.n21 a_14220_6400.n8 18.4942
R1242 a_14220_6400.n22 a_14220_6400.n7 18.4942
R1243 a_14220_6400.n23 a_14220_6400.n6 18.4942
R1244 a_14220_6400.n24 a_14220_6400.n5 18.4942
R1245 a_14220_6400.n25 a_14220_6400.n4 18.4942
R1246 a_14220_6400.n26 a_14220_6400.n3 18.4942
R1247 a_14220_6400.n27 a_14220_6400.n2 18.4942
R1248 a_14220_6400.n28 a_14220_6400.n1 18.4942
R1249 a_14220_6400.n56 a_14220_6400.n55 18.4942
R1250 a_14220_6400.n54 a_14220_6400.n29 18.4942
R1251 a_14220_6400.n53 a_14220_6400.n52 18.4942
R1252 a_14220_6400.n51 a_14220_6400.n30 18.4942
R1253 a_14220_6400.n50 a_14220_6400.n49 18.4942
R1254 a_14220_6400.n48 a_14220_6400.n31 18.4942
R1255 a_14220_6400.n47 a_14220_6400.n46 18.4942
R1256 a_14220_6400.n45 a_14220_6400.n32 18.4942
R1257 a_14220_6400.n44 a_14220_6400.n43 18.4942
R1258 a_14220_6400.n42 a_14220_6400.n33 18.4942
R1259 a_14220_6400.n41 a_14220_6400.n40 18.4942
R1260 a_14220_6400.n39 a_14220_6400.n34 18.4942
R1261 a_14220_6400.n38 a_14220_6400.n37 18.4942
R1262 a_14220_6400.n98 a_14220_6400.n90 15.388
R1263 a_14220_6400.n86 a_14220_6400.n85 11.6805
R1264 a_14220_6400.n87 a_14220_6400.n86 11.6805
R1265 a_14220_6400.n69 a_14220_6400.n68 11.6805
R1266 a_14220_6400.n70 a_14220_6400.n69 11.6805
R1267 a_14220_6400.n71 a_14220_6400.n70 11.6805
R1268 a_14220_6400.n72 a_14220_6400.n71 11.6805
R1269 a_14220_6400.n73 a_14220_6400.n72 11.6805
R1270 a_14220_6400.n87 a_14220_6400.n73 11.6805
R1271 a_14220_6400.n85 a_14220_6400.n74 11.6805
R1272 a_14220_6400.n81 a_14220_6400.n74 11.6805
R1273 a_14220_6400.n81 a_14220_6400.n80 11.6805
R1274 a_14220_6400.n80 a_14220_6400.n79 11.6805
R1275 a_14220_6400.n79 a_14220_6400.n76 11.6805
R1276 a_14220_6400.n57 a_14220_6400.n56 11.6805
R1277 a_14220_6400.n58 a_14220_6400.n57 11.6805
R1278 a_14220_6400.n16 a_14220_6400.n15 11.6805
R1279 a_14220_6400.n17 a_14220_6400.n16 11.6805
R1280 a_14220_6400.n18 a_14220_6400.n17 11.6805
R1281 a_14220_6400.n19 a_14220_6400.n18 11.6805
R1282 a_14220_6400.n20 a_14220_6400.n19 11.6805
R1283 a_14220_6400.n21 a_14220_6400.n20 11.6805
R1284 a_14220_6400.n22 a_14220_6400.n21 11.6805
R1285 a_14220_6400.n23 a_14220_6400.n22 11.6805
R1286 a_14220_6400.n24 a_14220_6400.n23 11.6805
R1287 a_14220_6400.n25 a_14220_6400.n24 11.6805
R1288 a_14220_6400.n26 a_14220_6400.n25 11.6805
R1289 a_14220_6400.n27 a_14220_6400.n26 11.6805
R1290 a_14220_6400.n28 a_14220_6400.n27 11.6805
R1291 a_14220_6400.n58 a_14220_6400.n28 11.6805
R1292 a_14220_6400.n56 a_14220_6400.n29 11.6805
R1293 a_14220_6400.n52 a_14220_6400.n29 11.6805
R1294 a_14220_6400.n52 a_14220_6400.n51 11.6805
R1295 a_14220_6400.n51 a_14220_6400.n50 11.6805
R1296 a_14220_6400.n50 a_14220_6400.n31 11.6805
R1297 a_14220_6400.n46 a_14220_6400.n31 11.6805
R1298 a_14220_6400.n46 a_14220_6400.n45 11.6805
R1299 a_14220_6400.n45 a_14220_6400.n44 11.6805
R1300 a_14220_6400.n44 a_14220_6400.n33 11.6805
R1301 a_14220_6400.n40 a_14220_6400.n33 11.6805
R1302 a_14220_6400.n40 a_14220_6400.n39 11.6805
R1303 a_14220_6400.n39 a_14220_6400.n38 11.6805
R1304 a_14220_6400.n38 a_14220_6400.n35 11.6805
R1305 a_14220_6400.n90 a_14220_6400.n60 10.688
R1306 a_14220_6400.n90 a_14220_6400.n89 9.24157
R1307 a_14220_6400.n78 a_14220_6400.n77 7.17687
R1308 a_14220_6400.n67 a_14220_6400.n66 7.17687
R1309 a_14220_6400.n37 a_14220_6400.n36 7.17687
R1310 a_14220_6400.n14 a_14220_6400.n13 7.17687
R1311 a_14220_6400.n99 a_14220_6400.n98 6.5392
R1312 a_14220_6400.n92 a_14220_6400.t11 5.7796
R1313 a_14220_6400.n104 a_14220_6400.t4 5.73764
R1314 a_14220_6400.n97 a_14220_6400.t5 5.59012
R1315 a_14220_6400.n99 a_14220_6400.t2 5.54817
R1316 a_14220_6400.n92 a_14220_6400.n91 5.38537
R1317 a_14220_6400.n94 a_14220_6400.n93 5.38537
R1318 a_14220_6400.n96 a_14220_6400.n95 5.38537
R1319 a_14220_6400.n105 a_14220_6400.n104 5.32067
R1320 a_14220_6400.n103 a_14220_6400.n102 5.32067
R1321 a_14220_6400.n101 a_14220_6400.n100 5.32067
R1322 a_14220_6400.n98 a_14220_6400.n97 4.61063
R1323 a_14220_6400.n68 a_14220_6400.n67 4.42851
R1324 a_14220_6400.n77 a_14220_6400.n76 4.42851
R1325 a_14220_6400.n15 a_14220_6400.n14 4.42851
R1326 a_14220_6400.n36 a_14220_6400.n35 4.42851
R1327 a_14220_6400.n105 a_14220_6400.t1 0.228
R1328 a_14220_6400.t0 a_14220_6400.n105 0.228
R1329 a_14220_6400.n102 a_14220_6400.t7 0.228
R1330 a_14220_6400.n102 a_14220_6400.t6 0.228
R1331 a_14220_6400.n100 a_14220_6400.t13 0.228
R1332 a_14220_6400.n100 a_14220_6400.t12 0.228
R1333 a_14220_6400.n91 a_14220_6400.t8 0.20525
R1334 a_14220_6400.n91 a_14220_6400.t3 0.20525
R1335 a_14220_6400.n93 a_14220_6400.t9 0.20525
R1336 a_14220_6400.n93 a_14220_6400.t15 0.20525
R1337 a_14220_6400.n95 a_14220_6400.t14 0.20525
R1338 a_14220_6400.n95 a_14220_6400.t10 0.20525
R1339 a_14220_6400.n101 a_14220_6400.n99 0.189974
R1340 a_14220_6400.n103 a_14220_6400.n101 0.189974
R1341 a_14220_6400.n104 a_14220_6400.n103 0.189974
R1342 a_14220_6400.n97 a_14220_6400.n96 0.189974
R1343 a_14220_6400.n96 a_14220_6400.n94 0.189974
R1344 a_14220_6400.n94 a_14220_6400.n92 0.189974
R1345 a_14220_6400.n84 a_14220_6400.n61 0.1205
R1346 a_14220_6400.n84 a_14220_6400.n83 0.1205
R1347 a_14220_6400.n83 a_14220_6400.n82 0.1205
R1348 a_14220_6400.n82 a_14220_6400.n75 0.1205
R1349 a_14220_6400.n78 a_14220_6400.n75 0.1205
R1350 a_14220_6400.n66 a_14220_6400.n65 0.1205
R1351 a_14220_6400.n65 a_14220_6400.n64 0.1205
R1352 a_14220_6400.n64 a_14220_6400.n63 0.1205
R1353 a_14220_6400.n63 a_14220_6400.n62 0.1205
R1354 a_14220_6400.n88 a_14220_6400.n62 0.1205
R1355 a_14220_6400.n55 a_14220_6400.n0 0.1205
R1356 a_14220_6400.n55 a_14220_6400.n54 0.1205
R1357 a_14220_6400.n54 a_14220_6400.n53 0.1205
R1358 a_14220_6400.n53 a_14220_6400.n30 0.1205
R1359 a_14220_6400.n49 a_14220_6400.n30 0.1205
R1360 a_14220_6400.n49 a_14220_6400.n48 0.1205
R1361 a_14220_6400.n48 a_14220_6400.n47 0.1205
R1362 a_14220_6400.n47 a_14220_6400.n32 0.1205
R1363 a_14220_6400.n43 a_14220_6400.n32 0.1205
R1364 a_14220_6400.n43 a_14220_6400.n42 0.1205
R1365 a_14220_6400.n42 a_14220_6400.n41 0.1205
R1366 a_14220_6400.n41 a_14220_6400.n34 0.1205
R1367 a_14220_6400.n37 a_14220_6400.n34 0.1205
R1368 a_14220_6400.n13 a_14220_6400.n12 0.1205
R1369 a_14220_6400.n12 a_14220_6400.n11 0.1205
R1370 a_14220_6400.n11 a_14220_6400.n10 0.1205
R1371 a_14220_6400.n10 a_14220_6400.n9 0.1205
R1372 a_14220_6400.n9 a_14220_6400.n8 0.1205
R1373 a_14220_6400.n8 a_14220_6400.n7 0.1205
R1374 a_14220_6400.n7 a_14220_6400.n6 0.1205
R1375 a_14220_6400.n6 a_14220_6400.n5 0.1205
R1376 a_14220_6400.n5 a_14220_6400.n4 0.1205
R1377 a_14220_6400.n4 a_14220_6400.n3 0.1205
R1378 a_14220_6400.n3 a_14220_6400.n2 0.1205
R1379 a_14220_6400.n2 a_14220_6400.n1 0.1205
R1380 a_14220_6400.n59 a_14220_6400.n1 0.1205
R1381 a_14220_6400.n89 a_14220_6400.n61 0.0485
R1382 a_14220_6400.n89 a_14220_6400.n88 0.0485
R1383 a_14220_6400.n60 a_14220_6400.n0 0.0485
R1384 a_14220_6400.n60 a_14220_6400.n59 0.0485
R1385 a_6924_6400.n15 a_6924_6400.t11 113.632
R1386 a_6924_6400.n19 a_6924_6400.t4 113.632
R1387 a_6924_6400.n2 a_6924_6400.t19 113.632
R1388 a_6924_6400.n6 a_6924_6400.t12 113.632
R1389 a_6924_6400.n22 a_6924_6400.t7 109.174
R1390 a_6924_6400.n23 a_6924_6400.t8 109.174
R1391 a_6924_6400.n16 a_6924_6400.t10 109.174
R1392 a_6924_6400.n17 a_6924_6400.t9 109.174
R1393 a_6924_6400.n21 a_6924_6400.t6 109.174
R1394 a_6924_6400.n18 a_6924_6400.t5 109.174
R1395 a_6924_6400.n9 a_6924_6400.t15 109.174
R1396 a_6924_6400.n10 a_6924_6400.t16 109.174
R1397 a_6924_6400.n3 a_6924_6400.t18 109.174
R1398 a_6924_6400.n4 a_6924_6400.t17 109.174
R1399 a_6924_6400.n8 a_6924_6400.t14 109.174
R1400 a_6924_6400.n5 a_6924_6400.t13 109.174
R1401 a_6924_6400.n22 a_6924_6400.n13 18.4942
R1402 a_6924_6400.n24 a_6924_6400.n23 18.4942
R1403 a_6924_6400.n17 a_6924_6400.n14 18.4942
R1404 a_6924_6400.n21 a_6924_6400.n20 18.4942
R1405 a_6924_6400.n9 a_6924_6400.n0 18.4942
R1406 a_6924_6400.n11 a_6924_6400.n10 18.4942
R1407 a_6924_6400.n4 a_6924_6400.n1 18.4942
R1408 a_6924_6400.n8 a_6924_6400.n7 18.4942
R1409 a_6924_6400.n28 a_6924_6400.n26 17.2799
R1410 a_6924_6400.n22 a_6924_6400.n21 11.6805
R1411 a_6924_6400.n23 a_6924_6400.n22 11.6805
R1412 a_6924_6400.n17 a_6924_6400.n16 11.6805
R1413 a_6924_6400.n23 a_6924_6400.n17 11.6805
R1414 a_6924_6400.n21 a_6924_6400.n18 11.6805
R1415 a_6924_6400.n9 a_6924_6400.n8 11.6805
R1416 a_6924_6400.n10 a_6924_6400.n9 11.6805
R1417 a_6924_6400.n4 a_6924_6400.n3 11.6805
R1418 a_6924_6400.n10 a_6924_6400.n4 11.6805
R1419 a_6924_6400.n8 a_6924_6400.n5 11.6805
R1420 a_6924_6400.n26 a_6924_6400.n12 10.013
R1421 a_6924_6400.n26 a_6924_6400.n25 9.91657
R1422 a_6924_6400.n20 a_6924_6400.n19 7.17687
R1423 a_6924_6400.n15 a_6924_6400.n14 7.17687
R1424 a_6924_6400.n7 a_6924_6400.n6 7.17687
R1425 a_6924_6400.n2 a_6924_6400.n1 7.17687
R1426 a_6924_6400.n29 a_6924_6400.n28 6.5392
R1427 a_6924_6400.n27 a_6924_6400.t3 5.7796
R1428 a_6924_6400.t1 a_6924_6400.n29 5.73764
R1429 a_6924_6400.n27 a_6924_6400.t2 5.59012
R1430 a_6924_6400.n29 a_6924_6400.t0 5.54817
R1431 a_6924_6400.n28 a_6924_6400.n27 4.61063
R1432 a_6924_6400.n16 a_6924_6400.n15 4.42851
R1433 a_6924_6400.n19 a_6924_6400.n18 4.42851
R1434 a_6924_6400.n3 a_6924_6400.n2 4.42851
R1435 a_6924_6400.n6 a_6924_6400.n5 4.42851
R1436 a_6924_6400.n20 a_6924_6400.n13 0.1205
R1437 a_6924_6400.n24 a_6924_6400.n14 0.1205
R1438 a_6924_6400.n7 a_6924_6400.n0 0.1205
R1439 a_6924_6400.n11 a_6924_6400.n1 0.1205
R1440 a_6924_6400.n25 a_6924_6400.n13 0.0485
R1441 a_6924_6400.n25 a_6924_6400.n24 0.0485
R1442 a_6924_6400.n12 a_6924_6400.n0 0.0485
R1443 a_6924_6400.n12 a_6924_6400.n11 0.0485
R1444 a_4812_6400.n15 a_4812_6400.t15 113.632
R1445 a_4812_6400.n19 a_4812_6400.t8 113.632
R1446 a_4812_6400.n2 a_4812_6400.t23 113.632
R1447 a_4812_6400.n6 a_4812_6400.t16 113.632
R1448 a_4812_6400.n22 a_4812_6400.t11 109.174
R1449 a_4812_6400.n23 a_4812_6400.t12 109.174
R1450 a_4812_6400.n16 a_4812_6400.t14 109.174
R1451 a_4812_6400.n17 a_4812_6400.t13 109.174
R1452 a_4812_6400.n21 a_4812_6400.t10 109.174
R1453 a_4812_6400.n18 a_4812_6400.t9 109.174
R1454 a_4812_6400.n9 a_4812_6400.t19 109.174
R1455 a_4812_6400.n10 a_4812_6400.t20 109.174
R1456 a_4812_6400.n3 a_4812_6400.t22 109.174
R1457 a_4812_6400.n4 a_4812_6400.t21 109.174
R1458 a_4812_6400.n8 a_4812_6400.t18 109.174
R1459 a_4812_6400.n5 a_4812_6400.t17 109.174
R1460 a_4812_6400.n22 a_4812_6400.n13 18.4942
R1461 a_4812_6400.n24 a_4812_6400.n23 18.4942
R1462 a_4812_6400.n17 a_4812_6400.n14 18.4942
R1463 a_4812_6400.n21 a_4812_6400.n20 18.4942
R1464 a_4812_6400.n9 a_4812_6400.n0 18.4942
R1465 a_4812_6400.n11 a_4812_6400.n10 18.4942
R1466 a_4812_6400.n4 a_4812_6400.n1 18.4942
R1467 a_4812_6400.n8 a_4812_6400.n7 18.4942
R1468 a_4812_6400.n30 a_4812_6400.n26 16.9914
R1469 a_4812_6400.n22 a_4812_6400.n21 11.6805
R1470 a_4812_6400.n23 a_4812_6400.n22 11.6805
R1471 a_4812_6400.n17 a_4812_6400.n16 11.6805
R1472 a_4812_6400.n23 a_4812_6400.n17 11.6805
R1473 a_4812_6400.n21 a_4812_6400.n18 11.6805
R1474 a_4812_6400.n9 a_4812_6400.n8 11.6805
R1475 a_4812_6400.n10 a_4812_6400.n9 11.6805
R1476 a_4812_6400.n4 a_4812_6400.n3 11.6805
R1477 a_4812_6400.n10 a_4812_6400.n4 11.6805
R1478 a_4812_6400.n8 a_4812_6400.n5 11.6805
R1479 a_4812_6400.n26 a_4812_6400.n12 10.3505
R1480 a_4812_6400.n26 a_4812_6400.n25 9.57907
R1481 a_4812_6400.n20 a_4812_6400.n19 7.17687
R1482 a_4812_6400.n15 a_4812_6400.n14 7.17687
R1483 a_4812_6400.n7 a_4812_6400.n6 7.17687
R1484 a_4812_6400.n2 a_4812_6400.n1 7.17687
R1485 a_4812_6400.n31 a_4812_6400.n30 6.5392
R1486 a_4812_6400.n28 a_4812_6400.t7 5.7796
R1487 a_4812_6400.t3 a_4812_6400.n33 5.73764
R1488 a_4812_6400.n29 a_4812_6400.t4 5.59012
R1489 a_4812_6400.n31 a_4812_6400.t0 5.54817
R1490 a_4812_6400.n28 a_4812_6400.n27 5.38537
R1491 a_4812_6400.n33 a_4812_6400.n32 5.32067
R1492 a_4812_6400.n30 a_4812_6400.n29 4.61063
R1493 a_4812_6400.n16 a_4812_6400.n15 4.42851
R1494 a_4812_6400.n19 a_4812_6400.n18 4.42851
R1495 a_4812_6400.n3 a_4812_6400.n2 4.42851
R1496 a_4812_6400.n6 a_4812_6400.n5 4.42851
R1497 a_4812_6400.n32 a_4812_6400.t1 0.228
R1498 a_4812_6400.n32 a_4812_6400.t2 0.228
R1499 a_4812_6400.n27 a_4812_6400.t5 0.20525
R1500 a_4812_6400.n27 a_4812_6400.t6 0.20525
R1501 a_4812_6400.n33 a_4812_6400.n31 0.189974
R1502 a_4812_6400.n29 a_4812_6400.n28 0.189974
R1503 a_4812_6400.n20 a_4812_6400.n13 0.1205
R1504 a_4812_6400.n24 a_4812_6400.n14 0.1205
R1505 a_4812_6400.n7 a_4812_6400.n0 0.1205
R1506 a_4812_6400.n11 a_4812_6400.n1 0.1205
R1507 a_4812_6400.n25 a_4812_6400.n13 0.0485
R1508 a_4812_6400.n25 a_4812_6400.n24 0.0485
R1509 a_4812_6400.n12 a_4812_6400.n0 0.0485
R1510 a_4812_6400.n12 a_4812_6400.n11 0.0485
R1511 a_2700_6400.n15 a_2700_6400.t15 113.632
R1512 a_2700_6400.n19 a_2700_6400.t8 113.632
R1513 a_2700_6400.n2 a_2700_6400.t23 113.632
R1514 a_2700_6400.n6 a_2700_6400.t16 113.632
R1515 a_2700_6400.n22 a_2700_6400.t11 109.174
R1516 a_2700_6400.n23 a_2700_6400.t12 109.174
R1517 a_2700_6400.n16 a_2700_6400.t14 109.174
R1518 a_2700_6400.n17 a_2700_6400.t13 109.174
R1519 a_2700_6400.n21 a_2700_6400.t10 109.174
R1520 a_2700_6400.n18 a_2700_6400.t9 109.174
R1521 a_2700_6400.n9 a_2700_6400.t19 109.174
R1522 a_2700_6400.n10 a_2700_6400.t20 109.174
R1523 a_2700_6400.n3 a_2700_6400.t22 109.174
R1524 a_2700_6400.n4 a_2700_6400.t21 109.174
R1525 a_2700_6400.n8 a_2700_6400.t18 109.174
R1526 a_2700_6400.n5 a_2700_6400.t17 109.174
R1527 a_2700_6400.n22 a_2700_6400.n13 18.4942
R1528 a_2700_6400.n24 a_2700_6400.n23 18.4942
R1529 a_2700_6400.n17 a_2700_6400.n14 18.4942
R1530 a_2700_6400.n21 a_2700_6400.n20 18.4942
R1531 a_2700_6400.n9 a_2700_6400.n0 18.4942
R1532 a_2700_6400.n11 a_2700_6400.n10 18.4942
R1533 a_2700_6400.n4 a_2700_6400.n1 18.4942
R1534 a_2700_6400.n8 a_2700_6400.n7 18.4942
R1535 a_2700_6400.n30 a_2700_6400.n26 16.7028
R1536 a_2700_6400.n22 a_2700_6400.n21 11.6805
R1537 a_2700_6400.n23 a_2700_6400.n22 11.6805
R1538 a_2700_6400.n17 a_2700_6400.n16 11.6805
R1539 a_2700_6400.n23 a_2700_6400.n17 11.6805
R1540 a_2700_6400.n21 a_2700_6400.n18 11.6805
R1541 a_2700_6400.n9 a_2700_6400.n8 11.6805
R1542 a_2700_6400.n10 a_2700_6400.n9 11.6805
R1543 a_2700_6400.n4 a_2700_6400.n3 11.6805
R1544 a_2700_6400.n10 a_2700_6400.n4 11.6805
R1545 a_2700_6400.n8 a_2700_6400.n5 11.6805
R1546 a_2700_6400.n26 a_2700_6400.n12 10.688
R1547 a_2700_6400.n26 a_2700_6400.n25 9.24157
R1548 a_2700_6400.n20 a_2700_6400.n19 7.17687
R1549 a_2700_6400.n15 a_2700_6400.n14 7.17687
R1550 a_2700_6400.n7 a_2700_6400.n6 7.17687
R1551 a_2700_6400.n2 a_2700_6400.n1 7.17687
R1552 a_2700_6400.n31 a_2700_6400.n30 6.5392
R1553 a_2700_6400.n28 a_2700_6400.t7 5.7796
R1554 a_2700_6400.t3 a_2700_6400.n33 5.73764
R1555 a_2700_6400.n29 a_2700_6400.t4 5.59012
R1556 a_2700_6400.n31 a_2700_6400.t0 5.54817
R1557 a_2700_6400.n28 a_2700_6400.n27 5.38537
R1558 a_2700_6400.n33 a_2700_6400.n32 5.32067
R1559 a_2700_6400.n30 a_2700_6400.n29 4.61063
R1560 a_2700_6400.n16 a_2700_6400.n15 4.42851
R1561 a_2700_6400.n19 a_2700_6400.n18 4.42851
R1562 a_2700_6400.n3 a_2700_6400.n2 4.42851
R1563 a_2700_6400.n6 a_2700_6400.n5 4.42851
R1564 a_2700_6400.n32 a_2700_6400.t1 0.228
R1565 a_2700_6400.n32 a_2700_6400.t2 0.228
R1566 a_2700_6400.n27 a_2700_6400.t5 0.20525
R1567 a_2700_6400.n27 a_2700_6400.t6 0.20525
R1568 a_2700_6400.n33 a_2700_6400.n31 0.189974
R1569 a_2700_6400.n29 a_2700_6400.n28 0.189974
R1570 a_2700_6400.n20 a_2700_6400.n13 0.1205
R1571 a_2700_6400.n24 a_2700_6400.n14 0.1205
R1572 a_2700_6400.n7 a_2700_6400.n0 0.1205
R1573 a_2700_6400.n11 a_2700_6400.n1 0.1205
R1574 a_2700_6400.n25 a_2700_6400.n13 0.0485
R1575 a_2700_6400.n25 a_2700_6400.n24 0.0485
R1576 a_2700_6400.n12 a_2700_6400.n0 0.0485
R1577 a_2700_6400.n12 a_2700_6400.n11 0.0485
R1578 a_14220_41600.n67 a_14220_41600.t31 113.632
R1579 a_14220_41600.n77 a_14220_41600.t16 113.632
R1580 a_14220_41600.n14 a_14220_41600.t63 113.632
R1581 a_14220_41600.n36 a_14220_41600.t32 113.632
R1582 a_14220_41600.n86 a_14220_41600.t23 109.174
R1583 a_14220_41600.n87 a_14220_41600.t24 109.174
R1584 a_14220_41600.n68 a_14220_41600.t30 109.174
R1585 a_14220_41600.n69 a_14220_41600.t29 109.174
R1586 a_14220_41600.n70 a_14220_41600.t28 109.174
R1587 a_14220_41600.n71 a_14220_41600.t27 109.174
R1588 a_14220_41600.n72 a_14220_41600.t26 109.174
R1589 a_14220_41600.n73 a_14220_41600.t25 109.174
R1590 a_14220_41600.n85 a_14220_41600.t22 109.174
R1591 a_14220_41600.n74 a_14220_41600.t21 109.174
R1592 a_14220_41600.n81 a_14220_41600.t20 109.174
R1593 a_14220_41600.n80 a_14220_41600.t19 109.174
R1594 a_14220_41600.n79 a_14220_41600.t18 109.174
R1595 a_14220_41600.n76 a_14220_41600.t17 109.174
R1596 a_14220_41600.n57 a_14220_41600.t47 109.174
R1597 a_14220_41600.n58 a_14220_41600.t48 109.174
R1598 a_14220_41600.n15 a_14220_41600.t62 109.174
R1599 a_14220_41600.n16 a_14220_41600.t61 109.174
R1600 a_14220_41600.n17 a_14220_41600.t60 109.174
R1601 a_14220_41600.n18 a_14220_41600.t59 109.174
R1602 a_14220_41600.n19 a_14220_41600.t58 109.174
R1603 a_14220_41600.n20 a_14220_41600.t57 109.174
R1604 a_14220_41600.n21 a_14220_41600.t56 109.174
R1605 a_14220_41600.n22 a_14220_41600.t55 109.174
R1606 a_14220_41600.n23 a_14220_41600.t54 109.174
R1607 a_14220_41600.n24 a_14220_41600.t53 109.174
R1608 a_14220_41600.n25 a_14220_41600.t52 109.174
R1609 a_14220_41600.n26 a_14220_41600.t51 109.174
R1610 a_14220_41600.n27 a_14220_41600.t50 109.174
R1611 a_14220_41600.n28 a_14220_41600.t49 109.174
R1612 a_14220_41600.n56 a_14220_41600.t46 109.174
R1613 a_14220_41600.n29 a_14220_41600.t45 109.174
R1614 a_14220_41600.n52 a_14220_41600.t44 109.174
R1615 a_14220_41600.n51 a_14220_41600.t43 109.174
R1616 a_14220_41600.n50 a_14220_41600.t42 109.174
R1617 a_14220_41600.n31 a_14220_41600.t41 109.174
R1618 a_14220_41600.n46 a_14220_41600.t40 109.174
R1619 a_14220_41600.n45 a_14220_41600.t39 109.174
R1620 a_14220_41600.n44 a_14220_41600.t38 109.174
R1621 a_14220_41600.n33 a_14220_41600.t37 109.174
R1622 a_14220_41600.n40 a_14220_41600.t36 109.174
R1623 a_14220_41600.n39 a_14220_41600.t35 109.174
R1624 a_14220_41600.n38 a_14220_41600.t34 109.174
R1625 a_14220_41600.n35 a_14220_41600.t33 109.174
R1626 a_14220_41600.n86 a_14220_41600.n61 18.4942
R1627 a_14220_41600.n88 a_14220_41600.n87 18.4942
R1628 a_14220_41600.n69 a_14220_41600.n66 18.4942
R1629 a_14220_41600.n70 a_14220_41600.n65 18.4942
R1630 a_14220_41600.n71 a_14220_41600.n64 18.4942
R1631 a_14220_41600.n72 a_14220_41600.n63 18.4942
R1632 a_14220_41600.n73 a_14220_41600.n62 18.4942
R1633 a_14220_41600.n85 a_14220_41600.n84 18.4942
R1634 a_14220_41600.n83 a_14220_41600.n74 18.4942
R1635 a_14220_41600.n82 a_14220_41600.n81 18.4942
R1636 a_14220_41600.n80 a_14220_41600.n75 18.4942
R1637 a_14220_41600.n79 a_14220_41600.n78 18.4942
R1638 a_14220_41600.n57 a_14220_41600.n0 18.4942
R1639 a_14220_41600.n59 a_14220_41600.n58 18.4942
R1640 a_14220_41600.n16 a_14220_41600.n13 18.4942
R1641 a_14220_41600.n17 a_14220_41600.n12 18.4942
R1642 a_14220_41600.n18 a_14220_41600.n11 18.4942
R1643 a_14220_41600.n19 a_14220_41600.n10 18.4942
R1644 a_14220_41600.n20 a_14220_41600.n9 18.4942
R1645 a_14220_41600.n21 a_14220_41600.n8 18.4942
R1646 a_14220_41600.n22 a_14220_41600.n7 18.4942
R1647 a_14220_41600.n23 a_14220_41600.n6 18.4942
R1648 a_14220_41600.n24 a_14220_41600.n5 18.4942
R1649 a_14220_41600.n25 a_14220_41600.n4 18.4942
R1650 a_14220_41600.n26 a_14220_41600.n3 18.4942
R1651 a_14220_41600.n27 a_14220_41600.n2 18.4942
R1652 a_14220_41600.n28 a_14220_41600.n1 18.4942
R1653 a_14220_41600.n56 a_14220_41600.n55 18.4942
R1654 a_14220_41600.n54 a_14220_41600.n29 18.4942
R1655 a_14220_41600.n53 a_14220_41600.n52 18.4942
R1656 a_14220_41600.n51 a_14220_41600.n30 18.4942
R1657 a_14220_41600.n50 a_14220_41600.n49 18.4942
R1658 a_14220_41600.n48 a_14220_41600.n31 18.4942
R1659 a_14220_41600.n47 a_14220_41600.n46 18.4942
R1660 a_14220_41600.n45 a_14220_41600.n32 18.4942
R1661 a_14220_41600.n44 a_14220_41600.n43 18.4942
R1662 a_14220_41600.n42 a_14220_41600.n33 18.4942
R1663 a_14220_41600.n41 a_14220_41600.n40 18.4942
R1664 a_14220_41600.n39 a_14220_41600.n34 18.4942
R1665 a_14220_41600.n38 a_14220_41600.n37 18.4942
R1666 a_14220_41600.n98 a_14220_41600.n90 15.388
R1667 a_14220_41600.n86 a_14220_41600.n85 11.6805
R1668 a_14220_41600.n87 a_14220_41600.n86 11.6805
R1669 a_14220_41600.n69 a_14220_41600.n68 11.6805
R1670 a_14220_41600.n70 a_14220_41600.n69 11.6805
R1671 a_14220_41600.n71 a_14220_41600.n70 11.6805
R1672 a_14220_41600.n72 a_14220_41600.n71 11.6805
R1673 a_14220_41600.n73 a_14220_41600.n72 11.6805
R1674 a_14220_41600.n87 a_14220_41600.n73 11.6805
R1675 a_14220_41600.n85 a_14220_41600.n74 11.6805
R1676 a_14220_41600.n81 a_14220_41600.n74 11.6805
R1677 a_14220_41600.n81 a_14220_41600.n80 11.6805
R1678 a_14220_41600.n80 a_14220_41600.n79 11.6805
R1679 a_14220_41600.n79 a_14220_41600.n76 11.6805
R1680 a_14220_41600.n57 a_14220_41600.n56 11.6805
R1681 a_14220_41600.n58 a_14220_41600.n57 11.6805
R1682 a_14220_41600.n16 a_14220_41600.n15 11.6805
R1683 a_14220_41600.n17 a_14220_41600.n16 11.6805
R1684 a_14220_41600.n18 a_14220_41600.n17 11.6805
R1685 a_14220_41600.n19 a_14220_41600.n18 11.6805
R1686 a_14220_41600.n20 a_14220_41600.n19 11.6805
R1687 a_14220_41600.n21 a_14220_41600.n20 11.6805
R1688 a_14220_41600.n22 a_14220_41600.n21 11.6805
R1689 a_14220_41600.n23 a_14220_41600.n22 11.6805
R1690 a_14220_41600.n24 a_14220_41600.n23 11.6805
R1691 a_14220_41600.n25 a_14220_41600.n24 11.6805
R1692 a_14220_41600.n26 a_14220_41600.n25 11.6805
R1693 a_14220_41600.n27 a_14220_41600.n26 11.6805
R1694 a_14220_41600.n28 a_14220_41600.n27 11.6805
R1695 a_14220_41600.n58 a_14220_41600.n28 11.6805
R1696 a_14220_41600.n56 a_14220_41600.n29 11.6805
R1697 a_14220_41600.n52 a_14220_41600.n29 11.6805
R1698 a_14220_41600.n52 a_14220_41600.n51 11.6805
R1699 a_14220_41600.n51 a_14220_41600.n50 11.6805
R1700 a_14220_41600.n50 a_14220_41600.n31 11.6805
R1701 a_14220_41600.n46 a_14220_41600.n31 11.6805
R1702 a_14220_41600.n46 a_14220_41600.n45 11.6805
R1703 a_14220_41600.n45 a_14220_41600.n44 11.6805
R1704 a_14220_41600.n44 a_14220_41600.n33 11.6805
R1705 a_14220_41600.n40 a_14220_41600.n33 11.6805
R1706 a_14220_41600.n40 a_14220_41600.n39 11.6805
R1707 a_14220_41600.n39 a_14220_41600.n38 11.6805
R1708 a_14220_41600.n38 a_14220_41600.n35 11.6805
R1709 a_14220_41600.n90 a_14220_41600.n60 10.688
R1710 a_14220_41600.n90 a_14220_41600.n89 9.24157
R1711 a_14220_41600.n78 a_14220_41600.n77 7.17687
R1712 a_14220_41600.n67 a_14220_41600.n66 7.17687
R1713 a_14220_41600.n37 a_14220_41600.n36 7.17687
R1714 a_14220_41600.n14 a_14220_41600.n13 7.17687
R1715 a_14220_41600.n99 a_14220_41600.n98 6.5392
R1716 a_14220_41600.n92 a_14220_41600.t4 5.7796
R1717 a_14220_41600.n104 a_14220_41600.t5 5.73764
R1718 a_14220_41600.n97 a_14220_41600.t12 5.59012
R1719 a_14220_41600.n99 a_14220_41600.t3 5.54817
R1720 a_14220_41600.n92 a_14220_41600.n91 5.38537
R1721 a_14220_41600.n94 a_14220_41600.n93 5.38537
R1722 a_14220_41600.n96 a_14220_41600.n95 5.38537
R1723 a_14220_41600.n105 a_14220_41600.n104 5.32067
R1724 a_14220_41600.n103 a_14220_41600.n102 5.32067
R1725 a_14220_41600.n101 a_14220_41600.n100 5.32067
R1726 a_14220_41600.n98 a_14220_41600.n97 4.61063
R1727 a_14220_41600.n68 a_14220_41600.n67 4.42851
R1728 a_14220_41600.n77 a_14220_41600.n76 4.42851
R1729 a_14220_41600.n15 a_14220_41600.n14 4.42851
R1730 a_14220_41600.n36 a_14220_41600.n35 4.42851
R1731 a_14220_41600.t0 a_14220_41600.n105 0.228
R1732 a_14220_41600.n105 a_14220_41600.t8 0.228
R1733 a_14220_41600.n102 a_14220_41600.t14 0.228
R1734 a_14220_41600.n102 a_14220_41600.t1 0.228
R1735 a_14220_41600.n100 a_14220_41600.t2 0.228
R1736 a_14220_41600.n100 a_14220_41600.t15 0.228
R1737 a_14220_41600.n91 a_14220_41600.t9 0.20525
R1738 a_14220_41600.n91 a_14220_41600.t7 0.20525
R1739 a_14220_41600.n93 a_14220_41600.t13 0.20525
R1740 a_14220_41600.n93 a_14220_41600.t10 0.20525
R1741 a_14220_41600.n95 a_14220_41600.t6 0.20525
R1742 a_14220_41600.n95 a_14220_41600.t11 0.20525
R1743 a_14220_41600.n101 a_14220_41600.n99 0.189974
R1744 a_14220_41600.n103 a_14220_41600.n101 0.189974
R1745 a_14220_41600.n104 a_14220_41600.n103 0.189974
R1746 a_14220_41600.n97 a_14220_41600.n96 0.189974
R1747 a_14220_41600.n96 a_14220_41600.n94 0.189974
R1748 a_14220_41600.n94 a_14220_41600.n92 0.189974
R1749 a_14220_41600.n84 a_14220_41600.n61 0.1205
R1750 a_14220_41600.n84 a_14220_41600.n83 0.1205
R1751 a_14220_41600.n83 a_14220_41600.n82 0.1205
R1752 a_14220_41600.n82 a_14220_41600.n75 0.1205
R1753 a_14220_41600.n78 a_14220_41600.n75 0.1205
R1754 a_14220_41600.n66 a_14220_41600.n65 0.1205
R1755 a_14220_41600.n65 a_14220_41600.n64 0.1205
R1756 a_14220_41600.n64 a_14220_41600.n63 0.1205
R1757 a_14220_41600.n63 a_14220_41600.n62 0.1205
R1758 a_14220_41600.n88 a_14220_41600.n62 0.1205
R1759 a_14220_41600.n55 a_14220_41600.n0 0.1205
R1760 a_14220_41600.n55 a_14220_41600.n54 0.1205
R1761 a_14220_41600.n54 a_14220_41600.n53 0.1205
R1762 a_14220_41600.n53 a_14220_41600.n30 0.1205
R1763 a_14220_41600.n49 a_14220_41600.n30 0.1205
R1764 a_14220_41600.n49 a_14220_41600.n48 0.1205
R1765 a_14220_41600.n48 a_14220_41600.n47 0.1205
R1766 a_14220_41600.n47 a_14220_41600.n32 0.1205
R1767 a_14220_41600.n43 a_14220_41600.n32 0.1205
R1768 a_14220_41600.n43 a_14220_41600.n42 0.1205
R1769 a_14220_41600.n42 a_14220_41600.n41 0.1205
R1770 a_14220_41600.n41 a_14220_41600.n34 0.1205
R1771 a_14220_41600.n37 a_14220_41600.n34 0.1205
R1772 a_14220_41600.n13 a_14220_41600.n12 0.1205
R1773 a_14220_41600.n12 a_14220_41600.n11 0.1205
R1774 a_14220_41600.n11 a_14220_41600.n10 0.1205
R1775 a_14220_41600.n10 a_14220_41600.n9 0.1205
R1776 a_14220_41600.n9 a_14220_41600.n8 0.1205
R1777 a_14220_41600.n8 a_14220_41600.n7 0.1205
R1778 a_14220_41600.n7 a_14220_41600.n6 0.1205
R1779 a_14220_41600.n6 a_14220_41600.n5 0.1205
R1780 a_14220_41600.n5 a_14220_41600.n4 0.1205
R1781 a_14220_41600.n4 a_14220_41600.n3 0.1205
R1782 a_14220_41600.n3 a_14220_41600.n2 0.1205
R1783 a_14220_41600.n2 a_14220_41600.n1 0.1205
R1784 a_14220_41600.n59 a_14220_41600.n1 0.1205
R1785 a_14220_41600.n89 a_14220_41600.n61 0.0485
R1786 a_14220_41600.n89 a_14220_41600.n88 0.0485
R1787 a_14220_41600.n60 a_14220_41600.n0 0.0485
R1788 a_14220_41600.n60 a_14220_41600.n59 0.0485
R1789 a_6924_41600.n15 a_6924_41600.t11 113.632
R1790 a_6924_41600.n19 a_6924_41600.t4 113.632
R1791 a_6924_41600.n2 a_6924_41600.t19 113.632
R1792 a_6924_41600.n6 a_6924_41600.t12 113.632
R1793 a_6924_41600.n22 a_6924_41600.t7 109.174
R1794 a_6924_41600.n23 a_6924_41600.t8 109.174
R1795 a_6924_41600.n16 a_6924_41600.t10 109.174
R1796 a_6924_41600.n17 a_6924_41600.t9 109.174
R1797 a_6924_41600.n21 a_6924_41600.t6 109.174
R1798 a_6924_41600.n18 a_6924_41600.t5 109.174
R1799 a_6924_41600.n9 a_6924_41600.t15 109.174
R1800 a_6924_41600.n10 a_6924_41600.t16 109.174
R1801 a_6924_41600.n3 a_6924_41600.t18 109.174
R1802 a_6924_41600.n4 a_6924_41600.t17 109.174
R1803 a_6924_41600.n8 a_6924_41600.t14 109.174
R1804 a_6924_41600.n5 a_6924_41600.t13 109.174
R1805 a_6924_41600.n22 a_6924_41600.n13 18.4942
R1806 a_6924_41600.n24 a_6924_41600.n23 18.4942
R1807 a_6924_41600.n17 a_6924_41600.n14 18.4942
R1808 a_6924_41600.n21 a_6924_41600.n20 18.4942
R1809 a_6924_41600.n9 a_6924_41600.n0 18.4942
R1810 a_6924_41600.n11 a_6924_41600.n10 18.4942
R1811 a_6924_41600.n4 a_6924_41600.n1 18.4942
R1812 a_6924_41600.n8 a_6924_41600.n7 18.4942
R1813 a_6924_41600.n28 a_6924_41600.n26 17.2799
R1814 a_6924_41600.n22 a_6924_41600.n21 11.6805
R1815 a_6924_41600.n23 a_6924_41600.n22 11.6805
R1816 a_6924_41600.n17 a_6924_41600.n16 11.6805
R1817 a_6924_41600.n23 a_6924_41600.n17 11.6805
R1818 a_6924_41600.n21 a_6924_41600.n18 11.6805
R1819 a_6924_41600.n9 a_6924_41600.n8 11.6805
R1820 a_6924_41600.n10 a_6924_41600.n9 11.6805
R1821 a_6924_41600.n4 a_6924_41600.n3 11.6805
R1822 a_6924_41600.n10 a_6924_41600.n4 11.6805
R1823 a_6924_41600.n8 a_6924_41600.n5 11.6805
R1824 a_6924_41600.n26 a_6924_41600.n12 10.013
R1825 a_6924_41600.n26 a_6924_41600.n25 9.91657
R1826 a_6924_41600.n20 a_6924_41600.n19 7.17687
R1827 a_6924_41600.n15 a_6924_41600.n14 7.17687
R1828 a_6924_41600.n7 a_6924_41600.n6 7.17687
R1829 a_6924_41600.n2 a_6924_41600.n1 7.17687
R1830 a_6924_41600.n29 a_6924_41600.n28 6.5392
R1831 a_6924_41600.n27 a_6924_41600.t3 5.7796
R1832 a_6924_41600.t1 a_6924_41600.n29 5.73764
R1833 a_6924_41600.n27 a_6924_41600.t2 5.59012
R1834 a_6924_41600.n29 a_6924_41600.t0 5.54817
R1835 a_6924_41600.n28 a_6924_41600.n27 4.61063
R1836 a_6924_41600.n16 a_6924_41600.n15 4.42851
R1837 a_6924_41600.n19 a_6924_41600.n18 4.42851
R1838 a_6924_41600.n3 a_6924_41600.n2 4.42851
R1839 a_6924_41600.n6 a_6924_41600.n5 4.42851
R1840 a_6924_41600.n20 a_6924_41600.n13 0.1205
R1841 a_6924_41600.n24 a_6924_41600.n14 0.1205
R1842 a_6924_41600.n7 a_6924_41600.n0 0.1205
R1843 a_6924_41600.n11 a_6924_41600.n1 0.1205
R1844 a_6924_41600.n25 a_6924_41600.n13 0.0485
R1845 a_6924_41600.n25 a_6924_41600.n24 0.0485
R1846 a_6924_41600.n12 a_6924_41600.n0 0.0485
R1847 a_6924_41600.n12 a_6924_41600.n11 0.0485
R1848 a_4812_41600.n15 a_4812_41600.t15 113.632
R1849 a_4812_41600.n19 a_4812_41600.t8 113.632
R1850 a_4812_41600.n2 a_4812_41600.t23 113.632
R1851 a_4812_41600.n6 a_4812_41600.t16 113.632
R1852 a_4812_41600.n22 a_4812_41600.t11 109.174
R1853 a_4812_41600.n23 a_4812_41600.t12 109.174
R1854 a_4812_41600.n16 a_4812_41600.t14 109.174
R1855 a_4812_41600.n17 a_4812_41600.t13 109.174
R1856 a_4812_41600.n21 a_4812_41600.t10 109.174
R1857 a_4812_41600.n18 a_4812_41600.t9 109.174
R1858 a_4812_41600.n9 a_4812_41600.t19 109.174
R1859 a_4812_41600.n10 a_4812_41600.t20 109.174
R1860 a_4812_41600.n3 a_4812_41600.t22 109.174
R1861 a_4812_41600.n4 a_4812_41600.t21 109.174
R1862 a_4812_41600.n8 a_4812_41600.t18 109.174
R1863 a_4812_41600.n5 a_4812_41600.t17 109.174
R1864 a_4812_41600.n22 a_4812_41600.n13 18.4942
R1865 a_4812_41600.n24 a_4812_41600.n23 18.4942
R1866 a_4812_41600.n17 a_4812_41600.n14 18.4942
R1867 a_4812_41600.n21 a_4812_41600.n20 18.4942
R1868 a_4812_41600.n9 a_4812_41600.n0 18.4942
R1869 a_4812_41600.n11 a_4812_41600.n10 18.4942
R1870 a_4812_41600.n4 a_4812_41600.n1 18.4942
R1871 a_4812_41600.n8 a_4812_41600.n7 18.4942
R1872 a_4812_41600.n30 a_4812_41600.n26 16.9914
R1873 a_4812_41600.n22 a_4812_41600.n21 11.6805
R1874 a_4812_41600.n23 a_4812_41600.n22 11.6805
R1875 a_4812_41600.n17 a_4812_41600.n16 11.6805
R1876 a_4812_41600.n23 a_4812_41600.n17 11.6805
R1877 a_4812_41600.n21 a_4812_41600.n18 11.6805
R1878 a_4812_41600.n9 a_4812_41600.n8 11.6805
R1879 a_4812_41600.n10 a_4812_41600.n9 11.6805
R1880 a_4812_41600.n4 a_4812_41600.n3 11.6805
R1881 a_4812_41600.n10 a_4812_41600.n4 11.6805
R1882 a_4812_41600.n8 a_4812_41600.n5 11.6805
R1883 a_4812_41600.n26 a_4812_41600.n12 10.3505
R1884 a_4812_41600.n26 a_4812_41600.n25 9.57907
R1885 a_4812_41600.n20 a_4812_41600.n19 7.17687
R1886 a_4812_41600.n15 a_4812_41600.n14 7.17687
R1887 a_4812_41600.n7 a_4812_41600.n6 7.17687
R1888 a_4812_41600.n2 a_4812_41600.n1 7.17687
R1889 a_4812_41600.n31 a_4812_41600.n30 6.5392
R1890 a_4812_41600.n28 a_4812_41600.t7 5.7796
R1891 a_4812_41600.t3 a_4812_41600.n33 5.73764
R1892 a_4812_41600.n29 a_4812_41600.t4 5.59012
R1893 a_4812_41600.n31 a_4812_41600.t0 5.54817
R1894 a_4812_41600.n28 a_4812_41600.n27 5.38537
R1895 a_4812_41600.n33 a_4812_41600.n32 5.32067
R1896 a_4812_41600.n30 a_4812_41600.n29 4.61063
R1897 a_4812_41600.n16 a_4812_41600.n15 4.42851
R1898 a_4812_41600.n19 a_4812_41600.n18 4.42851
R1899 a_4812_41600.n3 a_4812_41600.n2 4.42851
R1900 a_4812_41600.n6 a_4812_41600.n5 4.42851
R1901 a_4812_41600.n32 a_4812_41600.t1 0.228
R1902 a_4812_41600.n32 a_4812_41600.t2 0.228
R1903 a_4812_41600.n27 a_4812_41600.t5 0.20525
R1904 a_4812_41600.n27 a_4812_41600.t6 0.20525
R1905 a_4812_41600.n33 a_4812_41600.n31 0.189974
R1906 a_4812_41600.n29 a_4812_41600.n28 0.189974
R1907 a_4812_41600.n20 a_4812_41600.n13 0.1205
R1908 a_4812_41600.n24 a_4812_41600.n14 0.1205
R1909 a_4812_41600.n7 a_4812_41600.n0 0.1205
R1910 a_4812_41600.n11 a_4812_41600.n1 0.1205
R1911 a_4812_41600.n25 a_4812_41600.n13 0.0485
R1912 a_4812_41600.n25 a_4812_41600.n24 0.0485
R1913 a_4812_41600.n12 a_4812_41600.n0 0.0485
R1914 a_4812_41600.n12 a_4812_41600.n11 0.0485
R1915 a_2700_41600.n15 a_2700_41600.t15 113.632
R1916 a_2700_41600.n19 a_2700_41600.t8 113.632
R1917 a_2700_41600.n2 a_2700_41600.t23 113.632
R1918 a_2700_41600.n6 a_2700_41600.t16 113.632
R1919 a_2700_41600.n22 a_2700_41600.t11 109.174
R1920 a_2700_41600.n23 a_2700_41600.t12 109.174
R1921 a_2700_41600.n16 a_2700_41600.t14 109.174
R1922 a_2700_41600.n17 a_2700_41600.t13 109.174
R1923 a_2700_41600.n21 a_2700_41600.t10 109.174
R1924 a_2700_41600.n18 a_2700_41600.t9 109.174
R1925 a_2700_41600.n9 a_2700_41600.t19 109.174
R1926 a_2700_41600.n10 a_2700_41600.t20 109.174
R1927 a_2700_41600.n3 a_2700_41600.t22 109.174
R1928 a_2700_41600.n4 a_2700_41600.t21 109.174
R1929 a_2700_41600.n8 a_2700_41600.t18 109.174
R1930 a_2700_41600.n5 a_2700_41600.t17 109.174
R1931 a_2700_41600.n22 a_2700_41600.n13 18.4942
R1932 a_2700_41600.n24 a_2700_41600.n23 18.4942
R1933 a_2700_41600.n17 a_2700_41600.n14 18.4942
R1934 a_2700_41600.n21 a_2700_41600.n20 18.4942
R1935 a_2700_41600.n9 a_2700_41600.n0 18.4942
R1936 a_2700_41600.n11 a_2700_41600.n10 18.4942
R1937 a_2700_41600.n4 a_2700_41600.n1 18.4942
R1938 a_2700_41600.n8 a_2700_41600.n7 18.4942
R1939 a_2700_41600.n30 a_2700_41600.n26 16.7028
R1940 a_2700_41600.n22 a_2700_41600.n21 11.6805
R1941 a_2700_41600.n23 a_2700_41600.n22 11.6805
R1942 a_2700_41600.n17 a_2700_41600.n16 11.6805
R1943 a_2700_41600.n23 a_2700_41600.n17 11.6805
R1944 a_2700_41600.n21 a_2700_41600.n18 11.6805
R1945 a_2700_41600.n9 a_2700_41600.n8 11.6805
R1946 a_2700_41600.n10 a_2700_41600.n9 11.6805
R1947 a_2700_41600.n4 a_2700_41600.n3 11.6805
R1948 a_2700_41600.n10 a_2700_41600.n4 11.6805
R1949 a_2700_41600.n8 a_2700_41600.n5 11.6805
R1950 a_2700_41600.n26 a_2700_41600.n12 10.688
R1951 a_2700_41600.n26 a_2700_41600.n25 9.24157
R1952 a_2700_41600.n20 a_2700_41600.n19 7.17687
R1953 a_2700_41600.n15 a_2700_41600.n14 7.17687
R1954 a_2700_41600.n7 a_2700_41600.n6 7.17687
R1955 a_2700_41600.n2 a_2700_41600.n1 7.17687
R1956 a_2700_41600.n31 a_2700_41600.n30 6.5392
R1957 a_2700_41600.n28 a_2700_41600.t7 5.7796
R1958 a_2700_41600.t3 a_2700_41600.n33 5.73764
R1959 a_2700_41600.n29 a_2700_41600.t4 5.59012
R1960 a_2700_41600.n31 a_2700_41600.t0 5.54817
R1961 a_2700_41600.n28 a_2700_41600.n27 5.38537
R1962 a_2700_41600.n33 a_2700_41600.n32 5.32067
R1963 a_2700_41600.n30 a_2700_41600.n29 4.61063
R1964 a_2700_41600.n16 a_2700_41600.n15 4.42851
R1965 a_2700_41600.n19 a_2700_41600.n18 4.42851
R1966 a_2700_41600.n3 a_2700_41600.n2 4.42851
R1967 a_2700_41600.n6 a_2700_41600.n5 4.42851
R1968 a_2700_41600.n32 a_2700_41600.t1 0.228
R1969 a_2700_41600.n32 a_2700_41600.t2 0.228
R1970 a_2700_41600.n27 a_2700_41600.t5 0.20525
R1971 a_2700_41600.n27 a_2700_41600.t6 0.20525
R1972 a_2700_41600.n33 a_2700_41600.n31 0.189974
R1973 a_2700_41600.n29 a_2700_41600.n28 0.189974
R1974 a_2700_41600.n20 a_2700_41600.n13 0.1205
R1975 a_2700_41600.n24 a_2700_41600.n14 0.1205
R1976 a_2700_41600.n7 a_2700_41600.n0 0.1205
R1977 a_2700_41600.n11 a_2700_41600.n1 0.1205
R1978 a_2700_41600.n25 a_2700_41600.n13 0.0485
R1979 a_2700_41600.n25 a_2700_41600.n24 0.0485
R1980 a_2700_41600.n12 a_2700_41600.n0 0.0485
R1981 a_2700_41600.n12 a_2700_41600.n11 0.0485
C0 CLKN_H VDD 2.93876f
C1 O_CAPTURE_CLKB O_CAPTURE_CLK 0.13895f
C2 CLKP_H VDD 2.93876f
C3 E_CAPTURE_CLKB CLKP_HB 0.05079f
C4 O_CAPTURE_CLKB CLKN_HB 0.05079f
C5 VDD CLKP_HB 2.39439f
C6 E_CAPTURE_CLKB E_CAPTURE_CLK 0.13895f
C7 VDD E_SENSE 41.0029f
C8 VDD E_CAPTURE_CLK 11.2501f
C9 O_CAPTURE_CLK VDD 11.2501f
C10 O_CAPTURE_CLKB VDD 11.308f
C11 CLKN_HB VDD 2.39439f
C12 CLKP_H CLKP_HB 0.13381f
C13 E_CAPTURE_CLKB VDD 11.308f
C14 VDD O_SENSE 41.0029f
C15 CLKN_HB CLKN_H 0.13381f
C16 E_SENSE VSS 22.93374f
C17 E_CAPTURE_CLK VSS 13.22095f
C18 E_CAPTURE_CLKB VSS 11.51361f
C19 CLKP_H VSS 8.92236f
C20 CLKP_HB VSS 9.47043f
C21 O_SENSE VSS 22.93374f
C22 O_CAPTURE_CLK VSS 13.22095f
C23 O_CAPTURE_CLKB VSS 11.51361f
C24 CLKN_H VSS 8.92236f
C25 CLKN_HB VSS 9.93833f
C26 VDD VSS 2.37498p
C27 a_2700_41600.n0 VSS 0.0537f
C28 a_2700_41600.n1 VSS 0.18551f
C29 a_2700_41600.n2 VSS 0.0917f
C30 a_2700_41600.n3 VSS 0.09829f
C31 a_2700_41600.n4 VSS 0.09829f
C32 a_2700_41600.n5 VSS 0.09829f
C33 a_2700_41600.n6 VSS 0.0917f
C34 a_2700_41600.n7 VSS 0.18551f
C35 a_2700_41600.n8 VSS 0.09829f
C36 a_2700_41600.n9 VSS 0.09829f
C37 a_2700_41600.n10 VSS 0.09829f
C38 a_2700_41600.n11 VSS 0.0537f
C39 a_2700_41600.n12 VSS 0.30147f
C40 a_2700_41600.n13 VSS 0.0537f
C41 a_2700_41600.n14 VSS 0.18551f
C42 a_2700_41600.n15 VSS 0.0917f
C43 a_2700_41600.n16 VSS 0.09829f
C44 a_2700_41600.n17 VSS 0.09829f
C45 a_2700_41600.n18 VSS 0.09829f
C46 a_2700_41600.n19 VSS 0.0917f
C47 a_2700_41600.n20 VSS 0.18551f
C48 a_2700_41600.n21 VSS 0.09829f
C49 a_2700_41600.n22 VSS 0.09829f
C50 a_2700_41600.n23 VSS 0.09829f
C51 a_2700_41600.n24 VSS 0.0537f
C52 a_2700_41600.n25 VSS 0.2258f
C53 a_2700_41600.n26 VSS 1.98338f
C54 a_2700_41600.t7 VSS 0.78584f
C55 a_2700_41600.t6 VSS 0.18218f
C56 a_2700_41600.t5 VSS 0.18218f
C57 a_2700_41600.n27 VSS 0.57664f
C58 a_2700_41600.n28 VSS 0.32498f
C59 a_2700_41600.t4 VSS 0.78062f
C60 a_2700_41600.n29 VSS 0.23385f
C61 a_2700_41600.n30 VSS 1.84385f
C62 a_2700_41600.t0 VSS 0.78201f
C63 a_2700_41600.n31 VSS 0.34487f
C64 a_2700_41600.t2 VSS 0.18218f
C65 a_2700_41600.t1 VSS 0.18218f
C66 a_2700_41600.n32 VSS 0.58092f
C67 a_2700_41600.n33 VSS 0.31931f
C68 a_2700_41600.t3 VSS 0.78722f
C69 a_4812_41600.n0 VSS 0.05591f
C70 a_4812_41600.n1 VSS 0.19315f
C71 a_4812_41600.n2 VSS 0.09547f
C72 a_4812_41600.n3 VSS 0.10233f
C73 a_4812_41600.n4 VSS 0.10233f
C74 a_4812_41600.n5 VSS 0.10233f
C75 a_4812_41600.n6 VSS 0.09547f
C76 a_4812_41600.n7 VSS 0.19315f
C77 a_4812_41600.n8 VSS 0.10233f
C78 a_4812_41600.n9 VSS 0.10233f
C79 a_4812_41600.n10 VSS 0.10233f
C80 a_4812_41600.n11 VSS 0.05591f
C81 a_4812_41600.n12 VSS 0.29039f
C82 a_4812_41600.n13 VSS 0.05591f
C83 a_4812_41600.n14 VSS 0.19315f
C84 a_4812_41600.n15 VSS 0.09547f
C85 a_4812_41600.n16 VSS 0.10233f
C86 a_4812_41600.n17 VSS 0.10233f
C87 a_4812_41600.n18 VSS 0.10233f
C88 a_4812_41600.n19 VSS 0.09547f
C89 a_4812_41600.n20 VSS 0.19315f
C90 a_4812_41600.n21 VSS 0.10233f
C91 a_4812_41600.n22 VSS 0.10233f
C92 a_4812_41600.n23 VSS 0.10233f
C93 a_4812_41600.n24 VSS 0.05591f
C94 a_4812_41600.n25 VSS 0.24795f
C95 a_4812_41600.n26 VSS 2.13538f
C96 a_4812_41600.t7 VSS 0.80821f
C97 a_4812_41600.t6 VSS 0.1799f
C98 a_4812_41600.t5 VSS 0.1799f
C99 a_4812_41600.n27 VSS 0.60036f
C100 a_4812_41600.n28 VSS 0.33836f
C101 a_4812_41600.t4 VSS 0.80278f
C102 a_4812_41600.n29 VSS 0.24347f
C103 a_4812_41600.n30 VSS 1.89322f
C104 a_4812_41600.t0 VSS 0.80423f
C105 a_4812_41600.n31 VSS 0.35906f
C106 a_4812_41600.t2 VSS 0.1799f
C107 a_4812_41600.t1 VSS 0.1799f
C108 a_4812_41600.n32 VSS 0.60482f
C109 a_4812_41600.n33 VSS 0.33245f
C110 a_4812_41600.t3 VSS 0.80966f
C111 a_6924_41600.n0 VSS 0.05118f
C112 a_6924_41600.n1 VSS 0.17681f
C113 a_6924_41600.n2 VSS 0.08739f
C114 a_6924_41600.n3 VSS 0.09368f
C115 a_6924_41600.n4 VSS 0.09368f
C116 a_6924_41600.n5 VSS 0.09368f
C117 a_6924_41600.n6 VSS 0.08739f
C118 a_6924_41600.n7 VSS 0.17681f
C119 a_6924_41600.n8 VSS 0.09368f
C120 a_6924_41600.n9 VSS 0.09368f
C121 a_6924_41600.n10 VSS 0.09368f
C122 a_6924_41600.n11 VSS 0.05118f
C123 a_6924_41600.n12 VSS 0.24695f
C124 a_6924_41600.n13 VSS 0.05118f
C125 a_6924_41600.n14 VSS 0.17681f
C126 a_6924_41600.n15 VSS 0.08739f
C127 a_6924_41600.n16 VSS 0.09368f
C128 a_6924_41600.n17 VSS 0.09368f
C129 a_6924_41600.n18 VSS 0.09368f
C130 a_6924_41600.n19 VSS 0.08739f
C131 a_6924_41600.n20 VSS 0.17681f
C132 a_6924_41600.n21 VSS 0.09368f
C133 a_6924_41600.n22 VSS 0.09368f
C134 a_6924_41600.n23 VSS 0.09368f
C135 a_6924_41600.n24 VSS 0.05118f
C136 a_6924_41600.n25 VSS 0.24207f
C137 a_6924_41600.n26 VSS 2.01337f
C138 a_6924_41600.t3 VSS 0.75231f
C139 a_6924_41600.t2 VSS 0.74734f
C140 a_6924_41600.n27 VSS 0.36966f
C141 a_6924_41600.n28 VSS 1.70872f
C142 a_6924_41600.t0 VSS 0.74866f
C143 a_6924_41600.n29 VSS 0.47416f
C144 a_6924_41600.t1 VSS 0.75363f
C145 a_14220_41600.t8 VSS 0.20325f
C146 a_14220_41600.t5 VSS 0.80924f
C147 a_14220_41600.n0 VSS 0.05375f
C148 a_14220_41600.n1 VSS 0.06379f
C149 a_14220_41600.n2 VSS 0.06379f
C150 a_14220_41600.n3 VSS 0.06379f
C151 a_14220_41600.n4 VSS 0.06379f
C152 a_14220_41600.n5 VSS 0.06379f
C153 a_14220_41600.n6 VSS 0.06379f
C154 a_14220_41600.n7 VSS 0.06379f
C155 a_14220_41600.n8 VSS 0.06379f
C156 a_14220_41600.n9 VSS 0.06379f
C157 a_14220_41600.n10 VSS 0.06379f
C158 a_14220_41600.n11 VSS 0.06379f
C159 a_14220_41600.n12 VSS 0.06379f
C160 a_14220_41600.n13 VSS 0.18568f
C161 a_14220_41600.n14 VSS 0.09178f
C162 a_14220_41600.n15 VSS 0.09838f
C163 a_14220_41600.n16 VSS 0.09838f
C164 a_14220_41600.n17 VSS 0.09838f
C165 a_14220_41600.n18 VSS 0.09838f
C166 a_14220_41600.n19 VSS 0.09838f
C167 a_14220_41600.n20 VSS 0.09838f
C168 a_14220_41600.n21 VSS 0.09838f
C169 a_14220_41600.n22 VSS 0.09838f
C170 a_14220_41600.n23 VSS 0.09838f
C171 a_14220_41600.n24 VSS 0.09838f
C172 a_14220_41600.n25 VSS 0.09838f
C173 a_14220_41600.n26 VSS 0.09838f
C174 a_14220_41600.n27 VSS 0.09838f
C175 a_14220_41600.n28 VSS 0.09838f
C176 a_14220_41600.n29 VSS 0.09838f
C177 a_14220_41600.n30 VSS 0.06379f
C178 a_14220_41600.n31 VSS 0.09838f
C179 a_14220_41600.n32 VSS 0.06379f
C180 a_14220_41600.n33 VSS 0.09838f
C181 a_14220_41600.n34 VSS 0.06379f
C182 a_14220_41600.n35 VSS 0.09838f
C183 a_14220_41600.n36 VSS 0.09178f
C184 a_14220_41600.n37 VSS 0.18568f
C185 a_14220_41600.n38 VSS 0.09838f
C186 a_14220_41600.n39 VSS 0.09838f
C187 a_14220_41600.n40 VSS 0.09838f
C188 a_14220_41600.n41 VSS 0.06379f
C189 a_14220_41600.n42 VSS 0.06379f
C190 a_14220_41600.n43 VSS 0.06379f
C191 a_14220_41600.n44 VSS 0.09838f
C192 a_14220_41600.n45 VSS 0.09838f
C193 a_14220_41600.n46 VSS 0.09838f
C194 a_14220_41600.n47 VSS 0.06379f
C195 a_14220_41600.n48 VSS 0.06379f
C196 a_14220_41600.n49 VSS 0.06379f
C197 a_14220_41600.n50 VSS 0.09838f
C198 a_14220_41600.n51 VSS 0.09838f
C199 a_14220_41600.n52 VSS 0.09838f
C200 a_14220_41600.n53 VSS 0.06379f
C201 a_14220_41600.n54 VSS 0.06379f
C202 a_14220_41600.n55 VSS 0.06379f
C203 a_14220_41600.n56 VSS 0.09838f
C204 a_14220_41600.n57 VSS 0.09838f
C205 a_14220_41600.n58 VSS 0.09838f
C206 a_14220_41600.n59 VSS 0.05375f
C207 a_14220_41600.n60 VSS 0.97407f
C208 a_14220_41600.n61 VSS 0.05375f
C209 a_14220_41600.n62 VSS 0.06379f
C210 a_14220_41600.n63 VSS 0.06379f
C211 a_14220_41600.n64 VSS 0.06379f
C212 a_14220_41600.n65 VSS 0.06379f
C213 a_14220_41600.n66 VSS 0.18568f
C214 a_14220_41600.n67 VSS 0.09178f
C215 a_14220_41600.n68 VSS 0.09838f
C216 a_14220_41600.n69 VSS 0.09838f
C217 a_14220_41600.n70 VSS 0.09838f
C218 a_14220_41600.n71 VSS 0.09838f
C219 a_14220_41600.n72 VSS 0.09838f
C220 a_14220_41600.n73 VSS 0.09838f
C221 a_14220_41600.n74 VSS 0.09838f
C222 a_14220_41600.n75 VSS 0.06379f
C223 a_14220_41600.n76 VSS 0.09838f
C224 a_14220_41600.n77 VSS 0.09178f
C225 a_14220_41600.n78 VSS 0.18568f
C226 a_14220_41600.n79 VSS 0.09838f
C227 a_14220_41600.n80 VSS 0.09838f
C228 a_14220_41600.n81 VSS 0.09838f
C229 a_14220_41600.n82 VSS 0.06379f
C230 a_14220_41600.n83 VSS 0.06379f
C231 a_14220_41600.n84 VSS 0.06379f
C232 a_14220_41600.n85 VSS 0.09838f
C233 a_14220_41600.n86 VSS 0.09838f
C234 a_14220_41600.n87 VSS 0.09838f
C235 a_14220_41600.n88 VSS 0.05375f
C236 a_14220_41600.n89 VSS 0.4246f
C237 a_14220_41600.n90 VSS 2.49023f
C238 a_14220_41600.t4 VSS 0.80785f
C239 a_14220_41600.t7 VSS 0.20325f
C240 a_14220_41600.t9 VSS 0.20325f
C241 a_14220_41600.n91 VSS 0.57715f
C242 a_14220_41600.n92 VSS 0.32527f
C243 a_14220_41600.t10 VSS 0.20325f
C244 a_14220_41600.t13 VSS 0.20325f
C245 a_14220_41600.n93 VSS 0.57715f
C246 a_14220_41600.n94 VSS 0.17112f
C247 a_14220_41600.t11 VSS 0.20325f
C248 a_14220_41600.t6 VSS 0.20325f
C249 a_14220_41600.n95 VSS 0.57715f
C250 a_14220_41600.n96 VSS 0.17112f
C251 a_14220_41600.t12 VSS 0.80262f
C252 a_14220_41600.n97 VSS 0.23405f
C253 a_14220_41600.n98 VSS 1.68401f
C254 a_14220_41600.t3 VSS 0.80402f
C255 a_14220_41600.n99 VSS 0.34518f
C256 a_14220_41600.t15 VSS 0.20325f
C257 a_14220_41600.t2 VSS 0.20325f
C258 a_14220_41600.n100 VSS 0.58144f
C259 a_14220_41600.n101 VSS 0.16684f
C260 a_14220_41600.t1 VSS 0.20325f
C261 a_14220_41600.t14 VSS 0.20325f
C262 a_14220_41600.n102 VSS 0.58144f
C263 a_14220_41600.n103 VSS 0.16684f
C264 a_14220_41600.n104 VSS 0.3196f
C265 a_14220_41600.n105 VSS 0.58144f
C266 a_14220_41600.t0 VSS 0.20325f
C267 a_2700_6400.n0 VSS 0.0537f
C268 a_2700_6400.n1 VSS 0.18551f
C269 a_2700_6400.n2 VSS 0.0917f
C270 a_2700_6400.n3 VSS 0.09829f
C271 a_2700_6400.n4 VSS 0.09829f
C272 a_2700_6400.n5 VSS 0.09829f
C273 a_2700_6400.n6 VSS 0.0917f
C274 a_2700_6400.n7 VSS 0.18551f
C275 a_2700_6400.n8 VSS 0.09829f
C276 a_2700_6400.n9 VSS 0.09829f
C277 a_2700_6400.n10 VSS 0.09829f
C278 a_2700_6400.n11 VSS 0.0537f
C279 a_2700_6400.n12 VSS 0.30147f
C280 a_2700_6400.n13 VSS 0.0537f
C281 a_2700_6400.n14 VSS 0.18551f
C282 a_2700_6400.n15 VSS 0.0917f
C283 a_2700_6400.n16 VSS 0.09829f
C284 a_2700_6400.n17 VSS 0.09829f
C285 a_2700_6400.n18 VSS 0.09829f
C286 a_2700_6400.n19 VSS 0.0917f
C287 a_2700_6400.n20 VSS 0.18551f
C288 a_2700_6400.n21 VSS 0.09829f
C289 a_2700_6400.n22 VSS 0.09829f
C290 a_2700_6400.n23 VSS 0.09829f
C291 a_2700_6400.n24 VSS 0.0537f
C292 a_2700_6400.n25 VSS 0.2258f
C293 a_2700_6400.n26 VSS 1.98338f
C294 a_2700_6400.t7 VSS 0.78751f
C295 a_2700_6400.t6 VSS 0.18382f
C296 a_2700_6400.t5 VSS 0.18382f
C297 a_2700_6400.n27 VSS 0.57664f
C298 a_2700_6400.n28 VSS 0.32498f
C299 a_2700_6400.t4 VSS 0.78229f
C300 a_2700_6400.n29 VSS 0.23385f
C301 a_2700_6400.n30 VSS 1.84385f
C302 a_2700_6400.t0 VSS 0.78368f
C303 a_2700_6400.n31 VSS 0.34487f
C304 a_2700_6400.t2 VSS 0.18382f
C305 a_2700_6400.t1 VSS 0.18382f
C306 a_2700_6400.n32 VSS 0.58092f
C307 a_2700_6400.n33 VSS 0.31931f
C308 a_2700_6400.t3 VSS 0.7889f
C309 a_4812_6400.n0 VSS 0.05591f
C310 a_4812_6400.n1 VSS 0.19315f
C311 a_4812_6400.n2 VSS 0.09547f
C312 a_4812_6400.n3 VSS 0.10233f
C313 a_4812_6400.n4 VSS 0.10233f
C314 a_4812_6400.n5 VSS 0.10233f
C315 a_4812_6400.n6 VSS 0.09547f
C316 a_4812_6400.n7 VSS 0.19315f
C317 a_4812_6400.n8 VSS 0.10233f
C318 a_4812_6400.n9 VSS 0.10233f
C319 a_4812_6400.n10 VSS 0.10233f
C320 a_4812_6400.n11 VSS 0.05591f
C321 a_4812_6400.n12 VSS 0.29039f
C322 a_4812_6400.n13 VSS 0.05591f
C323 a_4812_6400.n14 VSS 0.19315f
C324 a_4812_6400.n15 VSS 0.09547f
C325 a_4812_6400.n16 VSS 0.10233f
C326 a_4812_6400.n17 VSS 0.10233f
C327 a_4812_6400.n18 VSS 0.10233f
C328 a_4812_6400.n19 VSS 0.09547f
C329 a_4812_6400.n20 VSS 0.19315f
C330 a_4812_6400.n21 VSS 0.10233f
C331 a_4812_6400.n22 VSS 0.10233f
C332 a_4812_6400.n23 VSS 0.10233f
C333 a_4812_6400.n24 VSS 0.05591f
C334 a_4812_6400.n25 VSS 0.24795f
C335 a_4812_6400.n26 VSS 2.13538f
C336 a_4812_6400.t7 VSS 0.80821f
C337 a_4812_6400.t6 VSS 0.1799f
C338 a_4812_6400.t5 VSS 0.1799f
C339 a_4812_6400.n27 VSS 0.60036f
C340 a_4812_6400.n28 VSS 0.33836f
C341 a_4812_6400.t4 VSS 0.80278f
C342 a_4812_6400.n29 VSS 0.24347f
C343 a_4812_6400.n30 VSS 1.89322f
C344 a_4812_6400.t0 VSS 0.80423f
C345 a_4812_6400.n31 VSS 0.35906f
C346 a_4812_6400.t2 VSS 0.1799f
C347 a_4812_6400.t1 VSS 0.1799f
C348 a_4812_6400.n32 VSS 0.60482f
C349 a_4812_6400.n33 VSS 0.33245f
C350 a_4812_6400.t3 VSS 0.80966f
C351 a_6924_6400.n0 VSS 0.05118f
C352 a_6924_6400.n1 VSS 0.17681f
C353 a_6924_6400.n2 VSS 0.08739f
C354 a_6924_6400.n3 VSS 0.09368f
C355 a_6924_6400.n4 VSS 0.09368f
C356 a_6924_6400.n5 VSS 0.09368f
C357 a_6924_6400.n6 VSS 0.08739f
C358 a_6924_6400.n7 VSS 0.17681f
C359 a_6924_6400.n8 VSS 0.09368f
C360 a_6924_6400.n9 VSS 0.09368f
C361 a_6924_6400.n10 VSS 0.09368f
C362 a_6924_6400.n11 VSS 0.05118f
C363 a_6924_6400.n12 VSS 0.24695f
C364 a_6924_6400.n13 VSS 0.05118f
C365 a_6924_6400.n14 VSS 0.17681f
C366 a_6924_6400.n15 VSS 0.08739f
C367 a_6924_6400.n16 VSS 0.09368f
C368 a_6924_6400.n17 VSS 0.09368f
C369 a_6924_6400.n18 VSS 0.09368f
C370 a_6924_6400.n19 VSS 0.08739f
C371 a_6924_6400.n20 VSS 0.17681f
C372 a_6924_6400.n21 VSS 0.09368f
C373 a_6924_6400.n22 VSS 0.09368f
C374 a_6924_6400.n23 VSS 0.09368f
C375 a_6924_6400.n24 VSS 0.05118f
C376 a_6924_6400.n25 VSS 0.24207f
C377 a_6924_6400.n26 VSS 2.01337f
C378 a_6924_6400.t3 VSS 0.75398f
C379 a_6924_6400.t2 VSS 0.74901f
C380 a_6924_6400.n27 VSS 0.36966f
C381 a_6924_6400.n28 VSS 1.70872f
C382 a_6924_6400.t0 VSS 0.75034f
C383 a_6924_6400.n29 VSS 0.47416f
C384 a_6924_6400.t1 VSS 0.7553f
C385 a_14220_6400.t1 VSS 0.20325f
C386 a_14220_6400.t4 VSS 0.80924f
C387 a_14220_6400.n0 VSS 0.05375f
C388 a_14220_6400.n1 VSS 0.06379f
C389 a_14220_6400.n2 VSS 0.06379f
C390 a_14220_6400.n3 VSS 0.06379f
C391 a_14220_6400.n4 VSS 0.06379f
C392 a_14220_6400.n5 VSS 0.06379f
C393 a_14220_6400.n6 VSS 0.06379f
C394 a_14220_6400.n7 VSS 0.06379f
C395 a_14220_6400.n8 VSS 0.06379f
C396 a_14220_6400.n9 VSS 0.06379f
C397 a_14220_6400.n10 VSS 0.06379f
C398 a_14220_6400.n11 VSS 0.06379f
C399 a_14220_6400.n12 VSS 0.06379f
C400 a_14220_6400.n13 VSS 0.18568f
C401 a_14220_6400.n14 VSS 0.09178f
C402 a_14220_6400.n15 VSS 0.09838f
C403 a_14220_6400.n16 VSS 0.09838f
C404 a_14220_6400.n17 VSS 0.09838f
C405 a_14220_6400.n18 VSS 0.09838f
C406 a_14220_6400.n19 VSS 0.09838f
C407 a_14220_6400.n20 VSS 0.09838f
C408 a_14220_6400.n21 VSS 0.09838f
C409 a_14220_6400.n22 VSS 0.09838f
C410 a_14220_6400.n23 VSS 0.09838f
C411 a_14220_6400.n24 VSS 0.09838f
C412 a_14220_6400.n25 VSS 0.09838f
C413 a_14220_6400.n26 VSS 0.09838f
C414 a_14220_6400.n27 VSS 0.09838f
C415 a_14220_6400.n28 VSS 0.09838f
C416 a_14220_6400.n29 VSS 0.09838f
C417 a_14220_6400.n30 VSS 0.06379f
C418 a_14220_6400.n31 VSS 0.09838f
C419 a_14220_6400.n32 VSS 0.06379f
C420 a_14220_6400.n33 VSS 0.09838f
C421 a_14220_6400.n34 VSS 0.06379f
C422 a_14220_6400.n35 VSS 0.09838f
C423 a_14220_6400.n36 VSS 0.09178f
C424 a_14220_6400.n37 VSS 0.18568f
C425 a_14220_6400.n38 VSS 0.09838f
C426 a_14220_6400.n39 VSS 0.09838f
C427 a_14220_6400.n40 VSS 0.09838f
C428 a_14220_6400.n41 VSS 0.06379f
C429 a_14220_6400.n42 VSS 0.06379f
C430 a_14220_6400.n43 VSS 0.06379f
C431 a_14220_6400.n44 VSS 0.09838f
C432 a_14220_6400.n45 VSS 0.09838f
C433 a_14220_6400.n46 VSS 0.09838f
C434 a_14220_6400.n47 VSS 0.06379f
C435 a_14220_6400.n48 VSS 0.06379f
C436 a_14220_6400.n49 VSS 0.06379f
C437 a_14220_6400.n50 VSS 0.09838f
C438 a_14220_6400.n51 VSS 0.09838f
C439 a_14220_6400.n52 VSS 0.09838f
C440 a_14220_6400.n53 VSS 0.06379f
C441 a_14220_6400.n54 VSS 0.06379f
C442 a_14220_6400.n55 VSS 0.06379f
C443 a_14220_6400.n56 VSS 0.09838f
C444 a_14220_6400.n57 VSS 0.09838f
C445 a_14220_6400.n58 VSS 0.09838f
C446 a_14220_6400.n59 VSS 0.05375f
C447 a_14220_6400.n60 VSS 0.97407f
C448 a_14220_6400.n61 VSS 0.05375f
C449 a_14220_6400.n62 VSS 0.06379f
C450 a_14220_6400.n63 VSS 0.06379f
C451 a_14220_6400.n64 VSS 0.06379f
C452 a_14220_6400.n65 VSS 0.06379f
C453 a_14220_6400.n66 VSS 0.18568f
C454 a_14220_6400.n67 VSS 0.09178f
C455 a_14220_6400.n68 VSS 0.09838f
C456 a_14220_6400.n69 VSS 0.09838f
C457 a_14220_6400.n70 VSS 0.09838f
C458 a_14220_6400.n71 VSS 0.09838f
C459 a_14220_6400.n72 VSS 0.09838f
C460 a_14220_6400.n73 VSS 0.09838f
C461 a_14220_6400.n74 VSS 0.09838f
C462 a_14220_6400.n75 VSS 0.06379f
C463 a_14220_6400.n76 VSS 0.09838f
C464 a_14220_6400.n77 VSS 0.09178f
C465 a_14220_6400.n78 VSS 0.18568f
C466 a_14220_6400.n79 VSS 0.09838f
C467 a_14220_6400.n80 VSS 0.09838f
C468 a_14220_6400.n81 VSS 0.09838f
C469 a_14220_6400.n82 VSS 0.06379f
C470 a_14220_6400.n83 VSS 0.06379f
C471 a_14220_6400.n84 VSS 0.06379f
C472 a_14220_6400.n85 VSS 0.09838f
C473 a_14220_6400.n86 VSS 0.09838f
C474 a_14220_6400.n87 VSS 0.09838f
C475 a_14220_6400.n88 VSS 0.05375f
C476 a_14220_6400.n89 VSS 0.4246f
C477 a_14220_6400.n90 VSS 2.49023f
C478 a_14220_6400.t11 VSS 0.80785f
C479 a_14220_6400.t3 VSS 0.20325f
C480 a_14220_6400.t8 VSS 0.20325f
C481 a_14220_6400.n91 VSS 0.57715f
C482 a_14220_6400.n92 VSS 0.32527f
C483 a_14220_6400.t15 VSS 0.20325f
C484 a_14220_6400.t9 VSS 0.20325f
C485 a_14220_6400.n93 VSS 0.57715f
C486 a_14220_6400.n94 VSS 0.17112f
C487 a_14220_6400.t10 VSS 0.20325f
C488 a_14220_6400.t14 VSS 0.20325f
C489 a_14220_6400.n95 VSS 0.57715f
C490 a_14220_6400.n96 VSS 0.17112f
C491 a_14220_6400.t5 VSS 0.80262f
C492 a_14220_6400.n97 VSS 0.23405f
C493 a_14220_6400.n98 VSS 1.68401f
C494 a_14220_6400.t2 VSS 0.80402f
C495 a_14220_6400.n99 VSS 0.34518f
C496 a_14220_6400.t12 VSS 0.20325f
C497 a_14220_6400.t13 VSS 0.20325f
C498 a_14220_6400.n100 VSS 0.58144f
C499 a_14220_6400.n101 VSS 0.16684f
C500 a_14220_6400.t6 VSS 0.20325f
C501 a_14220_6400.t7 VSS 0.20325f
C502 a_14220_6400.n102 VSS 0.58144f
C503 a_14220_6400.n103 VSS 0.16684f
C504 a_14220_6400.n104 VSS 0.3196f
C505 a_14220_6400.n105 VSS 0.58144f
C506 a_14220_6400.t0 VSS 0.20325f
C507 VSS.t195 VSS 0.09548f
C508 VSS.t197 VSS 0.09732f
C509 VSS.t141 VSS 0.09548f
C510 VSS.t143 VSS 0.09548f
C511 VSS.t181 VSS 0.09548f
C512 VSS.t183 VSS 0.09548f
C513 VSS.t121 VSS 0.09548f
C514 VSS.t123 VSS 0.09548f
C515 VSS.t37 VSS 0.09548f
C516 VSS.t39 VSS 0.09548f
C517 VSS.t1 VSS 0.09548f
C518 VSS.t3 VSS 0.09548f
C519 VSS.t131 VSS 0.09548f
C520 VSS.t133 VSS 0.09548f
C521 VSS.t9 VSS 0.09732f
C522 VSS.t11 VSS 0.09548f
C523 VSS.t71 VSS 0.09092f
C524 VSS.t15 VSS 0.09267f
C525 VSS.t43 VSS 0.09092f
C526 VSS.t45 VSS 0.09092f
C527 VSS.t41 VSS 0.09092f
C528 VSS.t147 VSS 0.09092f
C529 VSS.t47 VSS 0.09267f
C530 VSS.t13 VSS 0.09092f
C531 VSS.t19 VSS 0.09933f
C532 VSS.t169 VSS 0.10123f
C533 VSS.t75 VSS 0.09933f
C534 VSS.t17 VSS 0.09933f
C535 VSS.t187 VSS 0.09933f
C536 VSS.t73 VSS 0.09933f
C537 VSS.t161 VSS 0.10123f
C538 VSS.t185 VSS 0.09933f
C539 VSS.t129 VSS 0.0954f
C540 VSS.t25 VSS 0.09723f
C541 VSS.t145 VSS 0.0954f
C542 VSS.t139 VSS 0.0954f
C543 VSS.t65 VSS 0.0954f
C544 VSS.t179 VSS 0.0954f
C545 VSS.t193 VSS 0.09723f
C546 VSS.t199 VSS 0.0954f
C547 VSS.t91 VSS 0.07296f
C548 VSS.t95 VSS 0.07296f
C549 VSS.t79 VSS 0.06306f
C550 VSS.t77 VSS 0.06427f
C551 VSS.t83 VSS 0.06427f
C552 VSS.t81 VSS 0.06306f
C553 VSS.t99 VSS 0.07159f
C554 VSS.t93 VSS 0.07297f
C555 VSS.t97 VSS 0.07297f
C556 VSS.t101 VSS 0.07159f
C557 VSS.t153 VSS 0.06995f
C558 VSS.t151 VSS 0.07129f
C559 VSS.t157 VSS 0.07129f
C560 VSS.t155 VSS 0.06995f
C561 VSS.t175 VSS 0.06306f
C562 VSS.t171 VSS 0.06427f
C563 VSS.t177 VSS 0.06427f
C564 VSS.t173 VSS 0.06306f
C565 VSS.t159 VSS 0.07129f
C566 VSS.t149 VSS 0.07129f
C567 VSS.t33 VSS 0.0954f
C568 VSS.t35 VSS 0.09723f
C569 VSS.t103 VSS 0.0954f
C570 VSS.t105 VSS 0.0954f
C571 VSS.t109 VSS 0.0954f
C572 VSS.t111 VSS 0.0954f
C573 VSS.t55 VSS 0.09723f
C574 VSS.t167 VSS 0.0954f
C575 VSS.t163 VSS 0.09933f
C576 VSS.t165 VSS 0.10123f
C577 VSS.t29 VSS 0.09933f
C578 VSS.t31 VSS 0.09933f
C579 VSS.t85 VSS 0.09933f
C580 VSS.t87 VSS 0.09933f
C581 VSS.t51 VSS 0.10123f
C582 VSS.t53 VSS 0.09933f
C583 VSS.t49 VSS 0.09092f
C584 VSS.t113 VSS 0.09267f
C585 VSS.t115 VSS 0.09092f
C586 VSS.t107 VSS 0.09092f
C587 VSS.t69 VSS 0.09092f
C588 VSS.t89 VSS 0.09092f
C589 VSS.t27 VSS 0.09267f
C590 VSS.t67 VSS 0.09092f
C591 VSS.t117 VSS 0.09548f
C592 VSS.t119 VSS 0.09732f
C593 VSS.t189 VSS 0.09548f
C594 VSS.t191 VSS 0.09548f
C595 VSS.t125 VSS 0.09548f
C596 VSS.t127 VSS 0.09548f
C597 VSS.t5 VSS 0.09548f
C598 VSS.t7 VSS 0.09548f
C599 VSS.t135 VSS 0.09548f
C600 VSS.t137 VSS 0.09548f
C601 VSS.t61 VSS 0.09548f
C602 VSS.t63 VSS 0.09548f
C603 VSS.t57 VSS 0.09548f
C604 VSS.t59 VSS 0.09548f
C605 VSS.t21 VSS 0.09732f
C606 VSS.t23 VSS 0.09548f
C607 VDD.n1 VSS 1.12439f
C608 VDD.t142 VSS 0.61357f
C609 VDD.t144 VSS 0.10947f
C610 VDD.t146 VSS 0.10947f
C611 VDD.t150 VSS 0.61303f
C612 VDD.t134 VSS 0.61303f
C613 VDD.t130 VSS 0.10947f
C614 VDD.t132 VSS 0.10947f
C615 VDD.t136 VSS 0.61303f
C616 VDD.t148 VSS 0.61303f
C617 VDD.t152 VSS 0.61303f
C618 VDD.t188 VSS 0.61303f
C619 VDD.t162 VSS 0.10947f
C620 VDD.t52 VSS 0.10947f
C621 VDD.t250 VSS 0.10947f
C622 VDD.t78 VSS 0.10947f
C623 VDD.t244 VSS 0.10947f
C624 VDD.t20 VSS 0.10947f
C625 VDD.t102 VSS 0.61303f
C626 VDD.t42 VSS 0.61303f
C627 VDD.t128 VSS 0.10947f
C628 VDD.t126 VSS 0.10947f
C629 VDD.t160 VSS 0.10947f
C630 VDD.t158 VSS 0.10947f
C631 VDD.t192 VSS 0.10947f
C632 VDD.t190 VSS 0.10947f
C633 VDD.t234 VSS 0.61303f
C634 VDD.t38 VSS 0.61303f
C635 VDD.t124 VSS 0.10947f
C636 VDD.t122 VSS 0.10947f
C637 VDD.t76 VSS 0.10947f
C638 VDD.t74 VSS 0.10947f
C639 VDD.t10 VSS 0.10947f
C640 VDD.t8 VSS 0.10947f
C641 VDD.t40 VSS 0.61303f
C642 VDD.t112 VSS 0.61303f
C643 VDD.t110 VSS 0.10947f
C644 VDD.t68 VSS 0.10947f
C645 VDD.t66 VSS 0.10947f
C646 VDD.t2 VSS 0.10947f
C647 VDD.t0 VSS 0.10947f
C648 VDD.t32 VSS 0.10947f
C649 VDD.t30 VSS 0.10947f
C650 VDD.t116 VSS 0.10947f
C651 VDD.t114 VSS 0.10947f
C652 VDD.t196 VSS 0.10947f
C653 VDD.t194 VSS 0.10947f
C654 VDD.t72 VSS 0.10947f
C655 VDD.t70 VSS 0.10947f
C656 VDD.t6 VSS 0.10947f
C657 VDD.t4 VSS 0.10947f
C658 VDD.t36 VSS 0.10947f
C659 VDD.t34 VSS 0.10947f
C660 VDD.t120 VSS 0.10947f
C661 VDD.t118 VSS 0.10947f
C662 VDD.t166 VSS 0.10947f
C663 VDD.t164 VSS 0.10947f
C664 VDD.t174 VSS 0.10947f
C665 VDD.t172 VSS 0.10947f
C666 VDD.t248 VSS 0.10947f
C667 VDD.t246 VSS 0.10947f
C668 VDD.t182 VSS 0.10947f
C669 VDD.t180 VSS 0.10947f
C670 VDD.t186 VSS 0.10947f
C671 VDD.t184 VSS 0.10947f
C672 VDD.t156 VSS 0.10947f
C673 VDD.t154 VSS 0.73737f
C674 VDD.n2 VSS 2.80915f
C675 VDD.t111 VSS 0.10335f
C676 VDD.t113 VSS 0.10518f
C677 VDD.n3 VSS 0.04102f
C678 VDD.t67 VSS 0.10335f
C679 VDD.t69 VSS 0.10335f
C680 VDD.n4 VSS 0.0407f
C681 VDD.n5 VSS 0.02062f
C682 VDD.t1 VSS 0.10335f
C683 VDD.t3 VSS 0.10335f
C684 VDD.n6 VSS 0.0407f
C685 VDD.n7 VSS 0.01168f
C686 VDD.t31 VSS 0.10335f
C687 VDD.t33 VSS 0.10335f
C688 VDD.n8 VSS 0.0407f
C689 VDD.n9 VSS 0.01168f
C690 VDD.t115 VSS 0.10335f
C691 VDD.t117 VSS 0.10335f
C692 VDD.n10 VSS 0.0407f
C693 VDD.n11 VSS 0.01168f
C694 VDD.t195 VSS 0.10335f
C695 VDD.t197 VSS 0.10335f
C696 VDD.n12 VSS 0.0407f
C697 VDD.n13 VSS 0.01168f
C698 VDD.t71 VSS 0.10335f
C699 VDD.t73 VSS 0.10335f
C700 VDD.n14 VSS 0.0407f
C701 VDD.n15 VSS 0.01168f
C702 VDD.t5 VSS 0.10335f
C703 VDD.t7 VSS 0.10335f
C704 VDD.n16 VSS 0.0407f
C705 VDD.n17 VSS 0.01168f
C706 VDD.t35 VSS 0.10335f
C707 VDD.t37 VSS 0.10335f
C708 VDD.n18 VSS 0.0407f
C709 VDD.n19 VSS 0.01168f
C710 VDD.t119 VSS 0.10335f
C711 VDD.t121 VSS 0.10335f
C712 VDD.n20 VSS 0.0407f
C713 VDD.n21 VSS 0.01168f
C714 VDD.t165 VSS 0.10335f
C715 VDD.t167 VSS 0.10335f
C716 VDD.n22 VSS 0.0407f
C717 VDD.n23 VSS 0.01168f
C718 VDD.t173 VSS 0.10335f
C719 VDD.t175 VSS 0.10335f
C720 VDD.n24 VSS 0.0407f
C721 VDD.n25 VSS 0.01168f
C722 VDD.t247 VSS 0.10335f
C723 VDD.t249 VSS 0.10335f
C724 VDD.n26 VSS 0.0407f
C725 VDD.n27 VSS 0.01168f
C726 VDD.t181 VSS 0.10335f
C727 VDD.t183 VSS 0.10335f
C728 VDD.n28 VSS 0.0407f
C729 VDD.n29 VSS 0.01168f
C730 VDD.t185 VSS 0.10335f
C731 VDD.t187 VSS 0.10335f
C732 VDD.n30 VSS 0.0407f
C733 VDD.n31 VSS 0.01168f
C734 VDD.t155 VSS 0.10518f
C735 VDD.t157 VSS 0.10335f
C736 VDD.n32 VSS 0.0407f
C737 VDD.n33 VSS 0.04559f
C738 VDD.n34 VSS 0.63669f
C739 VDD.t125 VSS 0.09879f
C740 VDD.t39 VSS 0.10053f
C741 VDD.n35 VSS 0.04102f
C742 VDD.t77 VSS 0.09879f
C743 VDD.t123 VSS 0.09879f
C744 VDD.n36 VSS 0.0407f
C745 VDD.n37 VSS 0.02062f
C746 VDD.t11 VSS 0.09879f
C747 VDD.t75 VSS 0.09879f
C748 VDD.n38 VSS 0.0407f
C749 VDD.n39 VSS 0.01168f
C750 VDD.t41 VSS 0.10053f
C751 VDD.t9 VSS 0.09879f
C752 VDD.n40 VSS 0.0407f
C753 VDD.n41 VSS 0.04559f
C754 VDD.n42 VSS 0.73405f
C755 VDD.t129 VSS 0.10719f
C756 VDD.t43 VSS 0.10909f
C757 VDD.n43 VSS 0.04102f
C758 VDD.t161 VSS 0.10719f
C759 VDD.t127 VSS 0.10719f
C760 VDD.n44 VSS 0.0407f
C761 VDD.n45 VSS 0.02062f
C762 VDD.t193 VSS 0.10719f
C763 VDD.t159 VSS 0.10719f
C764 VDD.n46 VSS 0.0407f
C765 VDD.n47 VSS 0.01168f
C766 VDD.t235 VSS 0.10909f
C767 VDD.t191 VSS 0.10719f
C768 VDD.n48 VSS 0.0407f
C769 VDD.n49 VSS 0.04559f
C770 VDD.n50 VSS 0.44374f
C771 VDD.t163 VSS 0.10326f
C772 VDD.t189 VSS 0.10509f
C773 VDD.n51 VSS 0.04102f
C774 VDD.t251 VSS 0.10326f
C775 VDD.t53 VSS 0.10326f
C776 VDD.n52 VSS 0.0407f
C777 VDD.n53 VSS 0.02062f
C778 VDD.t245 VSS 0.10326f
C779 VDD.t79 VSS 0.10326f
C780 VDD.n54 VSS 0.0407f
C781 VDD.n55 VSS 0.01168f
C782 VDD.t103 VSS 0.10509f
C783 VDD.t21 VSS 0.10326f
C784 VDD.n56 VSS 0.0407f
C785 VDD.n57 VSS 0.04559f
C786 VDD.n58 VSS 0.44374f
C787 VDD.t153 VSS 0.08082f
C788 VDD.t149 VSS 0.08082f
C789 VDD.n59 VSS 0.06994f
C790 VDD.n60 VSS 0.3851f
C791 VDD.t131 VSS 0.07092f
C792 VDD.t135 VSS 0.07213f
C793 VDD.n61 VSS 0.04102f
C794 VDD.t137 VSS 0.07213f
C795 VDD.t133 VSS 0.07092f
C796 VDD.n62 VSS 0.0407f
C797 VDD.n63 VSS 0.05453f
C798 VDD.n64 VSS 0.32278f
C799 VDD.t145 VSS 0.07946f
C800 VDD.t143 VSS 0.08083f
C801 VDD.n65 VSS 0.04102f
C802 VDD.t151 VSS 0.08083f
C803 VDD.t147 VSS 0.07946f
C804 VDD.n66 VSS 0.0407f
C805 VDD.n67 VSS 0.05453f
C806 VDD.n68 VSS 0.34622f
C807 VDD.n69 VSS 0.16345f
C808 VDD.n70 VSS 4.49737f
C809 VDD.n71 VSS 28.2524f
C810 VDD.n72 VSS 59.8264f
C811 VDD.n73 VSS 1.12439f
C812 VDD.t204 VSS 0.61357f
C813 VDD.t200 VSS 0.10947f
C814 VDD.t208 VSS 0.10947f
C815 VDD.t202 VSS 0.61303f
C816 VDD.t238 VSS 0.61303f
C817 VDD.t242 VSS 0.10947f
C818 VDD.t240 VSS 0.10947f
C819 VDD.t236 VSS 0.61303f
C820 VDD.t206 VSS 0.61303f
C821 VDD.t198 VSS 0.61303f
C822 VDD.t64 VSS 0.61303f
C823 VDD.t62 VSS 0.10947f
C824 VDD.t28 VSS 0.10947f
C825 VDD.t26 VSS 0.10947f
C826 VDD.t108 VSS 0.10947f
C827 VDD.t106 VSS 0.10947f
C828 VDD.t92 VSS 0.10947f
C829 VDD.t90 VSS 0.61303f
C830 VDD.t60 VSS 0.61303f
C831 VDD.t58 VSS 0.10947f
C832 VDD.t140 VSS 0.10947f
C833 VDD.t138 VSS 0.10947f
C834 VDD.t212 VSS 0.10947f
C835 VDD.t210 VSS 0.10947f
C836 VDD.t220 VSS 0.10947f
C837 VDD.t218 VSS 0.61303f
C838 VDD.t56 VSS 0.61303f
C839 VDD.t54 VSS 0.10947f
C840 VDD.t178 VSS 0.10947f
C841 VDD.t176 VSS 0.10947f
C842 VDD.t24 VSS 0.10947f
C843 VDD.t22 VSS 0.10947f
C844 VDD.t104 VSS 0.10947f
C845 VDD.t80 VSS 0.61303f
C846 VDD.t216 VSS 0.61303f
C847 VDD.t214 VSS 0.10947f
C848 VDD.t254 VSS 0.10947f
C849 VDD.t252 VSS 0.10947f
C850 VDD.t224 VSS 0.10947f
C851 VDD.t222 VSS 0.10947f
C852 VDD.t258 VSS 0.10947f
C853 VDD.t256 VSS 0.10947f
C854 VDD.t262 VSS 0.10947f
C855 VDD.t260 VSS 0.10947f
C856 VDD.t228 VSS 0.10947f
C857 VDD.t226 VSS 0.10947f
C858 VDD.t232 VSS 0.10947f
C859 VDD.t230 VSS 0.10947f
C860 VDD.t14 VSS 0.10947f
C861 VDD.t12 VSS 0.10947f
C862 VDD.t96 VSS 0.10947f
C863 VDD.t94 VSS 0.10947f
C864 VDD.t84 VSS 0.10947f
C865 VDD.t82 VSS 0.10947f
C866 VDD.t46 VSS 0.10947f
C867 VDD.t44 VSS 0.10947f
C868 VDD.t170 VSS 0.10947f
C869 VDD.t168 VSS 0.10947f
C870 VDD.t18 VSS 0.10947f
C871 VDD.t16 VSS 0.10947f
C872 VDD.t100 VSS 0.10947f
C873 VDD.t98 VSS 0.10947f
C874 VDD.t88 VSS 0.10947f
C875 VDD.t86 VSS 0.10947f
C876 VDD.t50 VSS 0.10947f
C877 VDD.t48 VSS 0.73737f
C878 VDD.n74 VSS 2.80915f
C879 VDD.t215 VSS 0.10335f
C880 VDD.t217 VSS 0.10518f
C881 VDD.n75 VSS 0.04102f
C882 VDD.t253 VSS 0.10335f
C883 VDD.t255 VSS 0.10335f
C884 VDD.n76 VSS 0.0407f
C885 VDD.n77 VSS 0.02062f
C886 VDD.t223 VSS 0.10335f
C887 VDD.t225 VSS 0.10335f
C888 VDD.n78 VSS 0.0407f
C889 VDD.n79 VSS 0.01168f
C890 VDD.t257 VSS 0.10335f
C891 VDD.t259 VSS 0.10335f
C892 VDD.n80 VSS 0.0407f
C893 VDD.n81 VSS 0.01168f
C894 VDD.t261 VSS 0.10335f
C895 VDD.t263 VSS 0.10335f
C896 VDD.n82 VSS 0.0407f
C897 VDD.n83 VSS 0.01168f
C898 VDD.t227 VSS 0.10335f
C899 VDD.t229 VSS 0.10335f
C900 VDD.n84 VSS 0.0407f
C901 VDD.n85 VSS 0.01168f
C902 VDD.t231 VSS 0.10335f
C903 VDD.t233 VSS 0.10335f
C904 VDD.n86 VSS 0.0407f
C905 VDD.n87 VSS 0.01168f
C906 VDD.t13 VSS 0.10335f
C907 VDD.t15 VSS 0.10335f
C908 VDD.n88 VSS 0.0407f
C909 VDD.n89 VSS 0.01168f
C910 VDD.t95 VSS 0.10335f
C911 VDD.t97 VSS 0.10335f
C912 VDD.n90 VSS 0.0407f
C913 VDD.n91 VSS 0.01168f
C914 VDD.t83 VSS 0.10335f
C915 VDD.t85 VSS 0.10335f
C916 VDD.n92 VSS 0.0407f
C917 VDD.n93 VSS 0.01168f
C918 VDD.t45 VSS 0.10335f
C919 VDD.t47 VSS 0.10335f
C920 VDD.n94 VSS 0.0407f
C921 VDD.n95 VSS 0.01168f
C922 VDD.t169 VSS 0.10335f
C923 VDD.t171 VSS 0.10335f
C924 VDD.n96 VSS 0.0407f
C925 VDD.n97 VSS 0.01168f
C926 VDD.t17 VSS 0.10335f
C927 VDD.t19 VSS 0.10335f
C928 VDD.n98 VSS 0.0407f
C929 VDD.n99 VSS 0.01168f
C930 VDD.t99 VSS 0.10335f
C931 VDD.t101 VSS 0.10335f
C932 VDD.n100 VSS 0.0407f
C933 VDD.n101 VSS 0.01168f
C934 VDD.t87 VSS 0.10335f
C935 VDD.t89 VSS 0.10335f
C936 VDD.n102 VSS 0.0407f
C937 VDD.n103 VSS 0.01168f
C938 VDD.t49 VSS 0.10518f
C939 VDD.t51 VSS 0.10335f
C940 VDD.n104 VSS 0.0407f
C941 VDD.n105 VSS 0.04559f
C942 VDD.n106 VSS 0.63669f
C943 VDD.t55 VSS 0.09879f
C944 VDD.t57 VSS 0.10053f
C945 VDD.n107 VSS 0.04102f
C946 VDD.t177 VSS 0.09879f
C947 VDD.t179 VSS 0.09879f
C948 VDD.n108 VSS 0.0407f
C949 VDD.n109 VSS 0.02062f
C950 VDD.t23 VSS 0.09879f
C951 VDD.t25 VSS 0.09879f
C952 VDD.n110 VSS 0.0407f
C953 VDD.n111 VSS 0.01168f
C954 VDD.t81 VSS 0.10053f
C955 VDD.t105 VSS 0.09879f
C956 VDD.n112 VSS 0.0407f
C957 VDD.n113 VSS 0.04559f
C958 VDD.n114 VSS 0.73405f
C959 VDD.t59 VSS 0.10719f
C960 VDD.t61 VSS 0.10909f
C961 VDD.n115 VSS 0.04102f
C962 VDD.t139 VSS 0.10719f
C963 VDD.t141 VSS 0.10719f
C964 VDD.n116 VSS 0.0407f
C965 VDD.n117 VSS 0.02062f
C966 VDD.t211 VSS 0.10719f
C967 VDD.t213 VSS 0.10719f
C968 VDD.n118 VSS 0.0407f
C969 VDD.n119 VSS 0.01168f
C970 VDD.t219 VSS 0.10909f
C971 VDD.t221 VSS 0.10719f
C972 VDD.n120 VSS 0.0407f
C973 VDD.n121 VSS 0.04559f
C974 VDD.n122 VSS 0.44374f
C975 VDD.t63 VSS 0.10326f
C976 VDD.t65 VSS 0.10509f
C977 VDD.n123 VSS 0.04102f
C978 VDD.t27 VSS 0.10326f
C979 VDD.t29 VSS 0.10326f
C980 VDD.n124 VSS 0.0407f
C981 VDD.n125 VSS 0.02062f
C982 VDD.t107 VSS 0.10326f
C983 VDD.t109 VSS 0.10326f
C984 VDD.n126 VSS 0.0407f
C985 VDD.n127 VSS 0.01168f
C986 VDD.t91 VSS 0.10509f
C987 VDD.t93 VSS 0.10326f
C988 VDD.n128 VSS 0.0407f
C989 VDD.n129 VSS 0.04559f
C990 VDD.n130 VSS 0.44374f
C991 VDD.t199 VSS 0.07915f
C992 VDD.t207 VSS 0.07915f
C993 VDD.n131 VSS 0.06994f
C994 VDD.n132 VSS 0.3851f
C995 VDD.t243 VSS 0.07092f
C996 VDD.t239 VSS 0.07213f
C997 VDD.n133 VSS 0.04102f
C998 VDD.t237 VSS 0.07213f
C999 VDD.t241 VSS 0.07092f
C1000 VDD.n134 VSS 0.0407f
C1001 VDD.n135 VSS 0.05453f
C1002 VDD.n136 VSS 0.32278f
C1003 VDD.t201 VSS 0.07782f
C1004 VDD.t205 VSS 0.07916f
C1005 VDD.n137 VSS 0.04102f
C1006 VDD.t203 VSS 0.07916f
C1007 VDD.t209 VSS 0.07782f
C1008 VDD.n138 VSS 0.0407f
C1009 VDD.n139 VSS 0.05453f
C1010 VDD.n140 VSS 0.34622f
C1011 VDD.n141 VSS 0.16345f
C1012 VDD.n142 VSS 4.49737f
C1013 VDD.n143 VSS 27.8651f
C1014 VDD.n144 VSS 60.2137f
C1015 VDD.n146 VSS 0.01093f
C1016 CLKN_HB.n0 VSS 0.2421f
C1017 CLKN_HB.n1 VSS 0.20299f
C1018 CLKN_HB.n2 VSS 0.89628f
C1019 CLKN_HB.n3 VSS 0.06628f
C1020 CLKN_HB.n4 VSS 0.07207f
C1021 CLKN_HB.n5 VSS 0.07207f
C1022 CLKN_HB.n6 VSS 0.06628f
C1023 CLKN_HB.n7 VSS 0.31638f
C1024 CLKN_HB.n8 VSS 0.06628f
C1025 CLKN_HB.n9 VSS 0.07207f
C1026 CLKN_HB.n10 VSS 0.07207f
C1027 CLKN_HB.n11 VSS 0.06628f
C1028 CLKN_HB.n12 VSS 0.2557f
C1029 CLKN_HB.n13 VSS 0.65308f
C1030 CLKN_HB.n14 VSS 1.23443f
C1031 CLKN_H.n0 VSS 0.05975f
C1032 CLKN_H.n1 VSS 0.06497f
C1033 CLKN_H.n2 VSS 0.06497f
C1034 CLKN_H.n3 VSS 0.05975f
C1035 CLKN_H.n4 VSS 0.28519f
C1036 CLKN_H.n5 VSS 0.05975f
C1037 CLKN_H.n6 VSS 0.06497f
C1038 CLKN_H.n7 VSS 0.06497f
C1039 CLKN_H.n8 VSS 0.05975f
C1040 CLKN_H.n9 VSS 0.23049f
C1041 CLKN_H.n10 VSS 1.74315f
C1042 O_CAPTURE_CLKB.t7 VSS 1.05948f
C1043 O_CAPTURE_CLKB.t8 VSS 0.24624f
C1044 O_CAPTURE_CLKB.t9 VSS 0.24624f
C1045 O_CAPTURE_CLKB.n0 VSS 0.78079f
C1046 O_CAPTURE_CLKB.n1 VSS 0.42917f
C1047 O_CAPTURE_CLKB.t10 VSS 0.24624f
C1048 O_CAPTURE_CLKB.t0 VSS 0.24624f
C1049 O_CAPTURE_CLKB.n2 VSS 0.78079f
C1050 O_CAPTURE_CLKB.n3 VSS 0.22404f
C1051 O_CAPTURE_CLKB.t1 VSS 0.24624f
C1052 O_CAPTURE_CLKB.t2 VSS 0.24624f
C1053 O_CAPTURE_CLKB.n4 VSS 0.78079f
C1054 O_CAPTURE_CLKB.n5 VSS 0.22404f
C1055 O_CAPTURE_CLKB.t3 VSS 1.05247f
C1056 O_CAPTURE_CLKB.n6 VSS 0.46353f
C1057 O_CAPTURE_CLKB.t6 VSS 1.05761f
C1058 O_CAPTURE_CLKB.t15 VSS 0.24624f
C1059 O_CAPTURE_CLKB.t13 VSS 0.24624f
C1060 O_CAPTURE_CLKB.n7 VSS 0.77503f
C1061 O_CAPTURE_CLKB.n8 VSS 0.43679f
C1062 O_CAPTURE_CLKB.t14 VSS 0.24624f
C1063 O_CAPTURE_CLKB.t11 VSS 0.24624f
C1064 O_CAPTURE_CLKB.n9 VSS 0.77503f
C1065 O_CAPTURE_CLKB.n10 VSS 0.2298f
C1066 O_CAPTURE_CLKB.t12 VSS 0.24624f
C1067 O_CAPTURE_CLKB.t4 VSS 0.24624f
C1068 O_CAPTURE_CLKB.n11 VSS 0.77503f
C1069 O_CAPTURE_CLKB.n12 VSS 0.2298f
C1070 O_CAPTURE_CLKB.t5 VSS 1.0506f
C1071 O_CAPTURE_CLKB.n13 VSS 0.3143f
C1072 O_CAPTURE_CLKB.n14 VSS 1.00866f
C1073 O_CAPTURE_CLK.t12 VSS 1.02067f
C1074 O_CAPTURE_CLK.t13 VSS 0.24345f
C1075 O_CAPTURE_CLK.t10 VSS 0.24345f
C1076 O_CAPTURE_CLK.n0 VSS 0.74605f
C1077 O_CAPTURE_CLK.n1 VSS 0.41008f
C1078 O_CAPTURE_CLK.t11 VSS 0.24345f
C1079 O_CAPTURE_CLK.t6 VSS 0.24345f
C1080 O_CAPTURE_CLK.n2 VSS 0.74605f
C1081 O_CAPTURE_CLK.n3 VSS 0.21407f
C1082 O_CAPTURE_CLK.t7 VSS 0.24345f
C1083 O_CAPTURE_CLK.t0 VSS 0.24345f
C1084 O_CAPTURE_CLK.n4 VSS 0.74605f
C1085 O_CAPTURE_CLK.n5 VSS 0.21407f
C1086 O_CAPTURE_CLK.t1 VSS 1.01398f
C1087 O_CAPTURE_CLK.n6 VSS 0.44291f
C1088 O_CAPTURE_CLK.t4 VSS 1.01889f
C1089 O_CAPTURE_CLK.t5 VSS 0.24345f
C1090 O_CAPTURE_CLK.t8 VSS 0.24345f
C1091 O_CAPTURE_CLK.n7 VSS 0.74055f
C1092 O_CAPTURE_CLK.n8 VSS 0.41736f
C1093 O_CAPTURE_CLK.t9 VSS 0.24345f
C1094 O_CAPTURE_CLK.t2 VSS 0.24345f
C1095 O_CAPTURE_CLK.n9 VSS 0.74055f
C1096 O_CAPTURE_CLK.n10 VSS 0.21957f
C1097 O_CAPTURE_CLK.t3 VSS 0.24345f
C1098 O_CAPTURE_CLK.t14 VSS 0.24345f
C1099 O_CAPTURE_CLK.n11 VSS 0.74055f
C1100 O_CAPTURE_CLK.n12 VSS 0.21957f
C1101 O_CAPTURE_CLK.t15 VSS 1.01218f
C1102 O_CAPTURE_CLK.n13 VSS 0.30032f
C1103 O_CAPTURE_CLK.n14 VSS 1.53503f
C1104 O_SENSE.t8 VSS 1.33739f
C1105 O_SENSE.t9 VSS 0.28987f
C1106 O_SENSE.t14 VSS 0.28987f
C1107 O_SENSE.n0 VSS 1.00621f
C1108 O_SENSE.n1 VSS 0.55308f
C1109 O_SENSE.t15 VSS 0.28987f
C1110 O_SENSE.t20 VSS 0.28987f
C1111 O_SENSE.n2 VSS 1.00621f
C1112 O_SENSE.n3 VSS 0.28872f
C1113 O_SENSE.t21 VSS 0.28987f
C1114 O_SENSE.t2 VSS 0.28987f
C1115 O_SENSE.n4 VSS 1.00621f
C1116 O_SENSE.n5 VSS 0.28872f
C1117 O_SENSE.t3 VSS 0.28987f
C1118 O_SENSE.t24 VSS 0.28987f
C1119 O_SENSE.n6 VSS 1.00621f
C1120 O_SENSE.n7 VSS 0.28872f
C1121 O_SENSE.t25 VSS 0.28987f
C1122 O_SENSE.t6 VSS 0.28987f
C1123 O_SENSE.n8 VSS 1.00621f
C1124 O_SENSE.n9 VSS 0.28872f
C1125 O_SENSE.t7 VSS 0.28987f
C1126 O_SENSE.t12 VSS 0.28987f
C1127 O_SENSE.n10 VSS 1.00621f
C1128 O_SENSE.n11 VSS 0.28872f
C1129 O_SENSE.t13 VSS 0.28987f
C1130 O_SENSE.t18 VSS 0.28987f
C1131 O_SENSE.n12 VSS 1.00621f
C1132 O_SENSE.n13 VSS 0.28872f
C1133 O_SENSE.t19 VSS 0.28987f
C1134 O_SENSE.t0 VSS 0.28987f
C1135 O_SENSE.n14 VSS 1.00621f
C1136 O_SENSE.n15 VSS 0.28872f
C1137 O_SENSE.t1 VSS 0.28987f
C1138 O_SENSE.t38 VSS 0.28987f
C1139 O_SENSE.n16 VSS 1.00621f
C1140 O_SENSE.n17 VSS 0.28872f
C1141 O_SENSE.t39 VSS 0.28987f
C1142 O_SENSE.t36 VSS 0.28987f
C1143 O_SENSE.n18 VSS 1.00621f
C1144 O_SENSE.n19 VSS 0.28872f
C1145 O_SENSE.t37 VSS 0.28987f
C1146 O_SENSE.t46 VSS 0.28987f
C1147 O_SENSE.n20 VSS 1.00621f
C1148 O_SENSE.n21 VSS 0.28872f
C1149 O_SENSE.t47 VSS 0.28987f
C1150 O_SENSE.t44 VSS 0.28987f
C1151 O_SENSE.n22 VSS 1.00621f
C1152 O_SENSE.n23 VSS 0.28872f
C1153 O_SENSE.t45 VSS 0.28987f
C1154 O_SENSE.t34 VSS 0.28987f
C1155 O_SENSE.n24 VSS 1.00621f
C1156 O_SENSE.n25 VSS 0.28872f
C1157 O_SENSE.t35 VSS 0.28987f
C1158 O_SENSE.t42 VSS 0.28987f
C1159 O_SENSE.n26 VSS 1.00621f
C1160 O_SENSE.n27 VSS 0.28872f
C1161 O_SENSE.t43 VSS 0.28987f
C1162 O_SENSE.t32 VSS 0.28987f
C1163 O_SENSE.n28 VSS 1.00621f
C1164 O_SENSE.n29 VSS 0.28872f
C1165 O_SENSE.t33 VSS 1.32836f
C1166 O_SENSE.n30 VSS 1.15945f
C1167 O_SENSE.t10 VSS 1.33499f
C1168 O_SENSE.t11 VSS 0.28987f
C1169 O_SENSE.t16 VSS 0.28987f
C1170 O_SENSE.n31 VSS 0.99879f
C1171 O_SENSE.n32 VSS 0.5629f
C1172 O_SENSE.t17 VSS 0.28987f
C1173 O_SENSE.t22 VSS 0.28987f
C1174 O_SENSE.n33 VSS 0.99879f
C1175 O_SENSE.n34 VSS 0.29614f
C1176 O_SENSE.t23 VSS 0.28987f
C1177 O_SENSE.t30 VSS 0.28987f
C1178 O_SENSE.n35 VSS 0.99879f
C1179 O_SENSE.n36 VSS 0.29614f
C1180 O_SENSE.t31 VSS 0.28987f
C1181 O_SENSE.t4 VSS 0.28987f
C1182 O_SENSE.n37 VSS 0.99879f
C1183 O_SENSE.n38 VSS 0.29614f
C1184 O_SENSE.t5 VSS 0.28987f
C1185 O_SENSE.t28 VSS 0.28987f
C1186 O_SENSE.n39 VSS 0.99879f
C1187 O_SENSE.n40 VSS 0.29614f
C1188 O_SENSE.t29 VSS 0.28987f
C1189 O_SENSE.t40 VSS 0.28987f
C1190 O_SENSE.n41 VSS 0.99879f
C1191 O_SENSE.n42 VSS 0.29614f
C1192 O_SENSE.t41 VSS 0.28987f
C1193 O_SENSE.t26 VSS 0.28987f
C1194 O_SENSE.n43 VSS 0.99879f
C1195 O_SENSE.n44 VSS 0.29614f
C1196 O_SENSE.t27 VSS 1.32594f
C1197 O_SENSE.n45 VSS 0.44059f
C1198 O_SENSE.n46 VSS 2.23142f
C1199 CLKP_HB.n0 VSS 0.24777f
C1200 CLKP_HB.n1 VSS 0.20775f
C1201 CLKP_HB.n2 VSS 0.91729f
C1202 CLKP_HB.n3 VSS 0.06784f
C1203 CLKP_HB.n4 VSS 0.07376f
C1204 CLKP_HB.n5 VSS 0.07376f
C1205 CLKP_HB.n6 VSS 0.06784f
C1206 CLKP_HB.n7 VSS 0.3238f
C1207 CLKP_HB.n8 VSS 0.06784f
C1208 CLKP_HB.n9 VSS 0.07376f
C1209 CLKP_HB.n10 VSS 0.07376f
C1210 CLKP_HB.n11 VSS 0.06784f
C1211 CLKP_HB.n12 VSS 0.26169f
C1212 CLKP_HB.n13 VSS 0.66839f
C1213 CLKP_HB.n14 VSS 1.17028f
C1214 CLKP_H.n0 VSS 0.05975f
C1215 CLKP_H.n1 VSS 0.06497f
C1216 CLKP_H.n2 VSS 0.06497f
C1217 CLKP_H.n3 VSS 0.05975f
C1218 CLKP_H.n4 VSS 0.28519f
C1219 CLKP_H.n5 VSS 0.05975f
C1220 CLKP_H.n6 VSS 0.06497f
C1221 CLKP_H.n7 VSS 0.06497f
C1222 CLKP_H.n8 VSS 0.05975f
C1223 CLKP_H.n9 VSS 0.23049f
C1224 CLKP_H.n10 VSS 1.74315f
C1225 E_CAPTURE_CLKB.t5 VSS 1.05948f
C1226 E_CAPTURE_CLKB.t0 VSS 0.24624f
C1227 E_CAPTURE_CLKB.t12 VSS 0.24624f
C1228 E_CAPTURE_CLKB.n0 VSS 0.78079f
C1229 E_CAPTURE_CLKB.n1 VSS 0.42917f
C1230 E_CAPTURE_CLKB.t3 VSS 0.24624f
C1231 E_CAPTURE_CLKB.t14 VSS 0.24624f
C1232 E_CAPTURE_CLKB.n2 VSS 0.78079f
C1233 E_CAPTURE_CLKB.n3 VSS 0.22404f
C1234 E_CAPTURE_CLKB.t2 VSS 0.24624f
C1235 E_CAPTURE_CLKB.t6 VSS 0.24624f
C1236 E_CAPTURE_CLKB.n4 VSS 0.78079f
C1237 E_CAPTURE_CLKB.n5 VSS 0.22404f
C1238 E_CAPTURE_CLKB.t9 VSS 1.05247f
C1239 E_CAPTURE_CLKB.n6 VSS 0.46353f
C1240 E_CAPTURE_CLKB.t13 VSS 1.05761f
C1241 E_CAPTURE_CLKB.t15 VSS 0.24624f
C1242 E_CAPTURE_CLKB.t4 VSS 0.24624f
C1243 E_CAPTURE_CLKB.n7 VSS 0.77503f
C1244 E_CAPTURE_CLKB.n8 VSS 0.43679f
C1245 E_CAPTURE_CLKB.t11 VSS 0.24624f
C1246 E_CAPTURE_CLKB.t10 VSS 0.24624f
C1247 E_CAPTURE_CLKB.n9 VSS 0.77503f
C1248 E_CAPTURE_CLKB.n10 VSS 0.2298f
C1249 E_CAPTURE_CLKB.t8 VSS 0.24624f
C1250 E_CAPTURE_CLKB.t7 VSS 0.24624f
C1251 E_CAPTURE_CLKB.n11 VSS 0.77503f
C1252 E_CAPTURE_CLKB.n12 VSS 0.2298f
C1253 E_CAPTURE_CLKB.t1 VSS 1.0506f
C1254 E_CAPTURE_CLKB.n13 VSS 0.3143f
C1255 E_CAPTURE_CLKB.n14 VSS 1.00866f
C1256 E_CAPTURE_CLK.t13 VSS 1.02067f
C1257 E_CAPTURE_CLK.t9 VSS 0.24345f
C1258 E_CAPTURE_CLK.t10 VSS 0.24345f
C1259 E_CAPTURE_CLK.n0 VSS 0.74605f
C1260 E_CAPTURE_CLK.n1 VSS 0.41008f
C1261 E_CAPTURE_CLK.t7 VSS 0.24345f
C1262 E_CAPTURE_CLK.t8 VSS 0.24345f
C1263 E_CAPTURE_CLK.n2 VSS 0.74605f
C1264 E_CAPTURE_CLK.n3 VSS 0.21407f
C1265 E_CAPTURE_CLK.t3 VSS 0.24345f
C1266 E_CAPTURE_CLK.t4 VSS 0.24345f
C1267 E_CAPTURE_CLK.n4 VSS 0.74605f
C1268 E_CAPTURE_CLK.n5 VSS 0.21407f
C1269 E_CAPTURE_CLK.t0 VSS 1.01398f
C1270 E_CAPTURE_CLK.n6 VSS 0.44291f
C1271 E_CAPTURE_CLK.t11 VSS 1.01889f
C1272 E_CAPTURE_CLK.t14 VSS 0.24345f
C1273 E_CAPTURE_CLK.t15 VSS 0.24345f
C1274 E_CAPTURE_CLK.n7 VSS 0.74055f
C1275 E_CAPTURE_CLK.n8 VSS 0.41736f
C1276 E_CAPTURE_CLK.t5 VSS 0.24345f
C1277 E_CAPTURE_CLK.t6 VSS 0.24345f
C1278 E_CAPTURE_CLK.n9 VSS 0.74055f
C1279 E_CAPTURE_CLK.n10 VSS 0.21957f
C1280 E_CAPTURE_CLK.t1 VSS 0.24345f
C1281 E_CAPTURE_CLK.t2 VSS 0.24345f
C1282 E_CAPTURE_CLK.n11 VSS 0.74055f
C1283 E_CAPTURE_CLK.n12 VSS 0.21957f
C1284 E_CAPTURE_CLK.t12 VSS 1.01218f
C1285 E_CAPTURE_CLK.n13 VSS 0.30032f
C1286 E_CAPTURE_CLK.n14 VSS 1.53503f
C1287 E_SENSE.t24 VSS 1.33739f
C1288 E_SENSE.t25 VSS 0.28987f
C1289 E_SENSE.t34 VSS 0.28987f
C1290 E_SENSE.n0 VSS 1.00621f
C1291 E_SENSE.n1 VSS 0.55308f
C1292 E_SENSE.t35 VSS 0.28987f
C1293 E_SENSE.t30 VSS 0.28987f
C1294 E_SENSE.n2 VSS 1.00621f
C1295 E_SENSE.n3 VSS 0.28872f
C1296 E_SENSE.t31 VSS 0.28987f
C1297 E_SENSE.t42 VSS 0.28987f
C1298 E_SENSE.n4 VSS 1.00621f
C1299 E_SENSE.n5 VSS 0.28872f
C1300 E_SENSE.t43 VSS 0.28987f
C1301 E_SENSE.t28 VSS 0.28987f
C1302 E_SENSE.n6 VSS 1.00621f
C1303 E_SENSE.n7 VSS 0.28872f
C1304 E_SENSE.t29 VSS 0.28987f
C1305 E_SENSE.t26 VSS 0.28987f
C1306 E_SENSE.n8 VSS 1.00621f
C1307 E_SENSE.n9 VSS 0.28872f
C1308 E_SENSE.t27 VSS 0.28987f
C1309 E_SENSE.t22 VSS 0.28987f
C1310 E_SENSE.n10 VSS 1.00621f
C1311 E_SENSE.n11 VSS 0.28872f
C1312 E_SENSE.t23 VSS 0.28987f
C1313 E_SENSE.t8 VSS 0.28987f
C1314 E_SENSE.n12 VSS 1.00621f
C1315 E_SENSE.n13 VSS 0.28872f
C1316 E_SENSE.t9 VSS 0.28987f
C1317 E_SENSE.t2 VSS 0.28987f
C1318 E_SENSE.n14 VSS 1.00621f
C1319 E_SENSE.n15 VSS 0.28872f
C1320 E_SENSE.t3 VSS 0.28987f
C1321 E_SENSE.t14 VSS 0.28987f
C1322 E_SENSE.n16 VSS 1.00621f
C1323 E_SENSE.n17 VSS 0.28872f
C1324 E_SENSE.t15 VSS 0.28987f
C1325 E_SENSE.t40 VSS 0.28987f
C1326 E_SENSE.n18 VSS 1.00621f
C1327 E_SENSE.n19 VSS 0.28872f
C1328 E_SENSE.t41 VSS 0.28987f
C1329 E_SENSE.t20 VSS 0.28987f
C1330 E_SENSE.n20 VSS 1.00621f
C1331 E_SENSE.n21 VSS 0.28872f
C1332 E_SENSE.t21 VSS 0.28987f
C1333 E_SENSE.t6 VSS 0.28987f
C1334 E_SENSE.n22 VSS 1.00621f
C1335 E_SENSE.n23 VSS 0.28872f
C1336 E_SENSE.t7 VSS 0.28987f
C1337 E_SENSE.t0 VSS 0.28987f
C1338 E_SENSE.n24 VSS 1.00621f
C1339 E_SENSE.n25 VSS 0.28872f
C1340 E_SENSE.t1 VSS 0.28987f
C1341 E_SENSE.t12 VSS 0.28987f
C1342 E_SENSE.n26 VSS 1.00621f
C1343 E_SENSE.n27 VSS 0.28872f
C1344 E_SENSE.t13 VSS 0.28987f
C1345 E_SENSE.t18 VSS 0.28987f
C1346 E_SENSE.n28 VSS 1.00621f
C1347 E_SENSE.n29 VSS 0.28872f
C1348 E_SENSE.t19 VSS 1.32836f
C1349 E_SENSE.n30 VSS 1.15945f
C1350 E_SENSE.t10 VSS 1.33499f
C1351 E_SENSE.t11 VSS 0.28987f
C1352 E_SENSE.t36 VSS 0.28987f
C1353 E_SENSE.n31 VSS 0.99879f
C1354 E_SENSE.n32 VSS 0.5629f
C1355 E_SENSE.t37 VSS 0.28987f
C1356 E_SENSE.t4 VSS 0.28987f
C1357 E_SENSE.n33 VSS 0.99879f
C1358 E_SENSE.n34 VSS 0.29614f
C1359 E_SENSE.t5 VSS 0.28987f
C1360 E_SENSE.t16 VSS 0.28987f
C1361 E_SENSE.n35 VSS 0.99879f
C1362 E_SENSE.n36 VSS 0.29614f
C1363 E_SENSE.t17 VSS 0.28987f
C1364 E_SENSE.t32 VSS 0.28987f
C1365 E_SENSE.n37 VSS 0.99879f
C1366 E_SENSE.n38 VSS 0.29614f
C1367 E_SENSE.t33 VSS 0.28987f
C1368 E_SENSE.t44 VSS 0.28987f
C1369 E_SENSE.n39 VSS 0.99879f
C1370 E_SENSE.n40 VSS 0.29614f
C1371 E_SENSE.t45 VSS 0.28987f
C1372 E_SENSE.t38 VSS 0.28987f
C1373 E_SENSE.n41 VSS 0.99879f
C1374 E_SENSE.n42 VSS 0.29614f
C1375 E_SENSE.t39 VSS 0.28987f
C1376 E_SENSE.t46 VSS 0.28987f
C1377 E_SENSE.n43 VSS 0.99879f
C1378 E_SENSE.n44 VSS 0.29614f
C1379 E_SENSE.t47 VSS 1.32594f
C1380 E_SENSE.n45 VSS 0.44059f
C1381 E_SENSE.n46 VSS 2.23142f
.ends
