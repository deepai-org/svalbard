* PEX produced using /foss/tools/sak/sak-pex.sh with m=3 and s=1 (extresist threshold=0 mOhm, minres=1 mOhm, mindelay=0 ps)
* NGSPICE file created from local_clock_fanout_pex.ext - technology: gf180mcuD

.subckt local_clock_fanout_pex CLKP_H CLKP_HB CLKN_H CLKN_HB VDD VSS E_SENSE E_CAPTURE_CLK
+ E_CAPTURE_CLKB O_SENSE O_CAPTURE_CLK O_CAPTURE_CLKB
X0 VSS.t57 a_2700_41600.t13 O_CAPTURE_CLKB.t8 VSS.t56 nfet_03v3 ad=2.08p pd=8.52u as=2.08p ps=8.52u w=8u l=0.28u
X1 E_CAPTURE_CLKB.t11 a_2700_6400.t8 VSS.t155 VSS.t154 nfet_03v3 ad=3.52p pd=16.88u as=2.08p ps=8.52u w=8u l=0.28u
X2 VDD.t25 a_14540_41600.t63 O_SENSE.t6 VDD.t24 pfet_03v3 ad=2.08p pd=8.52u as=2.08p ps=8.52u w=8u l=0.28u
X3 VDD.t75 a_2700_6400.t17 E_CAPTURE_CLKB.t7 VDD.t74 pfet_03v3 ad=2.08p pd=8.52u as=2.08p ps=8.52u w=8u l=0.28u
X4 VDD.t179 a_14540_6400.t43 E_SENSE.t20 VDD.t178 pfet_03v3 ad=2.08p pd=8.52u as=2.08p ps=8.52u w=8u l=0.28u
X5 VDD.t197 a_2700_41600.t19 O_CAPTURE_CLKB.t9 VDD.t196 pfet_03v3 ad=2.08p pd=8.52u as=2.08p ps=8.52u w=8u l=0.28u
X6 VSS.t185 a_6924_6400.t11 a_14540_6400.t21 VSS.t184 nfet_03v3 ad=2.08p pd=8.52u as=2.08p ps=8.52u w=8u l=0.28u
X7 O_SENSE.t3 a_14540_41600.t48 VDD.t9 VDD.t8 pfet_03v3 ad=2.08p pd=8.52u as=2.08p ps=8.52u w=8u l=0.28u
X8 O_CAPTURE_CLKB.t13 a_2700_41600.t10 VSS.t187 VSS.t186 nfet_03v3 ad=2.08p pd=8.52u as=2.08p ps=8.52u w=8u l=0.28u
X9 VSS.t191 a_6924_6400.t9 a_14540_6400.t22 VSS.t190 nfet_03v3 ad=2.08p pd=8.52u as=2.08p ps=8.52u w=8u l=0.28u
X10 VSS.t121 CLKP_HB.t1 a_6924_6400.t2 VSS.t120 nfet_03v3 ad=2.08p pd=8.52u as=2.08p ps=8.52u w=8u l=0.28u
X11 a_14540_6400.t8 a_6924_6400.t24 VDD.t169 VDD.t168 pfet_03v3 ad=2.08p pd=8.52u as=2.08p ps=8.52u w=8u l=0.28u
X12 a_6924_6400.t5 CLKP_HB.t10 VDD.t151 VDD.t150 pfet_03v3 ad=2.08p pd=8.52u as=2.08p ps=8.52u w=8u l=0.28u
X13 VSS.t63 a_4812_6400.t15 E_CAPTURE_CLK.t11 VSS.t62 nfet_03v3 ad=2.08p pd=8.52u as=3.52p ps=16.88u w=8u l=0.28u
X14 a_14540_6400.t6 a_6924_6400.t22 VDD.t115 VDD.t114 pfet_03v3 ad=2.08p pd=8.52u as=2.08p ps=8.52u w=8u l=0.28u
X15 VDD.t3 a_14540_41600.t57 O_SENSE.t0 VDD.t2 pfet_03v3 ad=2.08p pd=8.52u as=2.08p ps=8.52u w=8u l=0.28u
X16 VDD.t123 a_14540_41600.t69 O_SENSE.t42 VDD.t122 pfet_03v3 ad=2.08p pd=8.52u as=2.08p ps=8.52u w=8u l=0.28u
X17 VSS.t35 a_4812_6400.t13 E_CAPTURE_CLK.t7 VSS.t34 nfet_03v3 ad=2.08p pd=8.52u as=2.08p ps=8.52u w=8u l=0.28u
X18 O_SENSE.t21 a_14540_41600.t32 VSS.t41 VSS.t40 nfet_03v3 ad=2.08p pd=8.52u as=2.08p ps=8.52u w=8u l=0.28u
X19 E_SENSE.t38 a_14540_6400.t70 VDD.t269 VDD.t268 pfet_03v3 ad=2.08p pd=8.52u as=2.08p ps=8.52u w=8u l=0.28u
X20 O_SENSE.t26 a_14540_41600.t54 VDD.t91 VDD.t90 pfet_03v3 ad=2.08p pd=8.52u as=2.08p ps=8.52u w=8u l=0.28u
X21 VDD.t153 CLKP_HB.t11 a_6924_6400.t4 VDD.t152 pfet_03v3 ad=2.08p pd=8.52u as=3.52p ps=16.88u w=8u l=0.28u
X22 VSS.t85 a_14540_6400.t31 E_SENSE.t14 VSS.t84 nfet_03v3 ad=2.08p pd=8.52u as=2.08p ps=8.52u w=8u l=0.28u
X23 O_SENSE.t36 a_14540_41600.t66 VDD.t109 VDD.t108 pfet_03v3 ad=2.08p pd=8.52u as=2.08p ps=8.52u w=8u l=0.28u
X24 E_CAPTURE_CLKB.t3 a_2700_6400.t14 VSS.t43 VSS.t42 nfet_03v3 ad=2.08p pd=8.52u as=2.08p ps=8.52u w=8u l=0.28u
X25 VSS.t9 a_14540_41600.t29 O_SENSE.t4 VSS.t8 nfet_03v3 ad=2.08p pd=8.52u as=2.08p ps=8.52u w=8u l=0.28u
X26 E_CAPTURE_CLK.t8 a_4812_6400.t14 VSS.t37 VSS.t36 nfet_03v3 ad=2.08p pd=8.52u as=2.08p ps=8.52u w=8u l=0.28u
X27 VDD.t187 a_14540_6400.t71 E_SENSE.t22 VDD.t186 pfet_03v3 ad=2.08p pd=8.52u as=3.52p ps=16.88u w=8u l=0.28u
X28 a_14540_41600.t22 a_6924_41600.t16 VSS.t219 VSS.t218 nfet_03v3 ad=2.08p pd=8.52u as=2.08p ps=8.52u w=8u l=0.28u
X29 E_SENSE.t15 a_14540_6400.t32 VSS.t87 VSS.t86 nfet_03v3 ad=2.08p pd=8.52u as=2.08p ps=8.52u w=8u l=0.28u
X30 E_CAPTURE_CLK.t13 a_4812_6400.t8 VSS.t65 VSS.t64 nfet_03v3 ad=3.52p pd=16.88u as=2.08p ps=8.52u w=8u l=0.28u
X31 E_SENSE.t2 a_14540_6400.t38 VSS.t3 VSS.t2 nfet_03v3 ad=2.08p pd=8.52u as=2.08p ps=8.52u w=8u l=0.28u
X32 VSS.t175 a_2700_6400.t15 E_CAPTURE_CLKB.t12 VSS.t174 nfet_03v3 ad=2.08p pd=8.52u as=3.52p ps=16.88u w=8u l=0.28u
X33 VDD.t279 a_14540_6400.t65 E_SENSE.t43 VDD.t278 pfet_03v3 ad=2.08p pd=8.52u as=2.08p ps=8.52u w=8u l=0.28u
X34 a_14540_41600.t5 a_6924_41600.t26 VDD.t241 VDD.t240 pfet_03v3 ad=2.08p pd=8.52u as=2.08p ps=8.52u w=8u l=0.28u
X35 VDD.t165 a_14540_6400.t57 E_SENSE.t18 VDD.t164 pfet_03v3 ad=2.08p pd=8.52u as=2.08p ps=8.52u w=8u l=0.28u
X36 O_CAPTURE_CLKB.t4 a_2700_41600.t16 VDD.t47 VDD.t46 pfet_03v3 ad=3.52p pd=16.88u as=2.08p ps=8.52u w=8u l=0.28u
X37 O_CAPTURE_CLK.t4 a_4812_41600.t14 VSS.t47 VSS.t46 nfet_03v3 ad=2.08p pd=8.52u as=2.08p ps=8.52u w=8u l=0.28u
X38 VSS.t21 a_4812_6400.t9 E_CAPTURE_CLK.t5 VSS.t20 nfet_03v3 ad=2.08p pd=8.52u as=2.08p ps=8.52u w=8u l=0.28u
X39 O_CAPTURE_CLK.t8 a_4812_41600.t20 VDD.t61 VDD.t60 pfet_03v3 ad=2.08p pd=8.52u as=2.08p ps=8.52u w=8u l=0.28u
X40 VDD.t255 a_6924_41600.t23 a_14540_41600.t14 VDD.t254 pfet_03v3 ad=2.08p pd=8.52u as=2.08p ps=8.52u w=8u l=0.28u
X41 O_SENSE.t11 a_14540_41600.t46 VDD.t35 VDD.t34 pfet_03v3 ad=2.08p pd=8.52u as=2.08p ps=8.52u w=8u l=0.28u
X42 E_CAPTURE_CLK.t4 a_4812_6400.t18 VDD.t23 VDD.t22 pfet_03v3 ad=2.08p pd=8.52u as=2.08p ps=8.52u w=8u l=0.28u
X43 VSS.t195 a_14540_6400.t39 E_SENSE.t36 VSS.t194 nfet_03v3 ad=2.08p pd=8.52u as=3.52p ps=16.88u w=8u l=0.28u
X44 E_SENSE.t7 a_14540_6400.t66 VDD.t71 VDD.t70 pfet_03v3 ad=2.08p pd=8.52u as=2.08p ps=8.52u w=8u l=0.28u
X45 a_4812_41600.t1 CLKN_H.t2 VSS.t149 VSS.t148 nfet_03v3 ad=2.08p pd=8.52u as=2.08p ps=8.52u w=8u l=0.28u
X46 E_SENSE.t19 a_14540_6400.t58 VDD.t167 VDD.t166 pfet_03v3 ad=2.08p pd=8.52u as=2.08p ps=8.52u w=8u l=0.28u
X47 VSS.t127 a_4812_41600.t11 O_CAPTURE_CLK.t13 VSS.t126 nfet_03v3 ad=2.08p pd=8.52u as=2.08p ps=8.52u w=8u l=0.28u
X48 E_SENSE.t6 a_14540_6400.t64 VDD.t59 VDD.t58 pfet_03v3 ad=2.08p pd=8.52u as=2.08p ps=8.52u w=8u l=0.28u
X49 a_4812_41600.t7 CLKN_H.t4 VDD.t239 VDD.t238 pfet_03v3 ad=3.52p pd=16.88u as=2.08p ps=8.52u w=8u l=0.28u
X50 VSS.t177 a_14540_6400.t25 E_SENSE.t34 VSS.t176 nfet_03v3 ad=2.08p pd=8.52u as=2.08p ps=8.52u w=8u l=0.28u
X51 E_CAPTURE_CLKB.t15 a_2700_6400.t10 VSS.t223 VSS.t222 nfet_03v3 ad=2.08p pd=8.52u as=2.08p ps=8.52u w=8u l=0.28u
X52 VDD.t177 a_4812_41600.t17 O_CAPTURE_CLK.t11 VDD.t176 pfet_03v3 ad=2.08p pd=8.52u as=2.08p ps=8.52u w=8u l=0.28u
X53 VDD.t93 a_14540_41600.t43 O_SENSE.t27 VDD.t92 pfet_03v3 ad=2.08p pd=8.52u as=2.08p ps=8.52u w=8u l=0.28u
X54 VSS.t99 CLKN_HB.t5 a_2700_41600.t2 VSS.t98 nfet_03v3 ad=2.08p pd=8.52u as=2.08p ps=8.52u w=8u l=0.28u
X55 a_6924_41600.t1 CLKN_HB.t2 VSS.t103 VSS.t102 nfet_03v3 ad=2.08p pd=8.52u as=2.08p ps=8.52u w=8u l=0.28u
X56 VDD.t13 a_2700_6400.t19 E_CAPTURE_CLKB.t1 VDD.t12 pfet_03v3 ad=2.08p pd=8.52u as=2.08p ps=8.52u w=8u l=0.28u
X57 VSS.t141 a_6924_41600.t19 a_14540_41600.t2 VSS.t140 nfet_03v3 ad=2.08p pd=8.52u as=3.52p ps=16.88u w=8u l=0.28u
X58 VDD.t257 a_4812_6400.t19 E_CAPTURE_CLK.t14 VDD.t256 pfet_03v3 ad=2.08p pd=8.52u as=2.08p ps=8.52u w=8u l=0.28u
X59 a_2700_6400.t1 CLKP_HB.t6 VSS.t113 VSS.t112 nfet_03v3 ad=2.08p pd=8.52u as=2.08p ps=8.52u w=8u l=0.28u
X60 E_SENSE.t28 a_14540_6400.t50 VDD.t223 VDD.t222 pfet_03v3 ad=2.08p pd=8.52u as=2.08p ps=8.52u w=8u l=0.28u
X61 a_6924_41600.t7 CLKN_HB.t8 VDD.t133 VDD.t132 pfet_03v3 ad=3.52p pd=16.88u as=2.08p ps=8.52u w=8u l=0.28u
X62 VDD.t287 a_6924_41600.t29 a_14540_41600.t19 VDD.t286 pfet_03v3 ad=2.08p pd=8.52u as=2.08p ps=8.52u w=8u l=0.28u
X63 O_SENSE.t34 a_14540_41600.t52 VDD.t105 VDD.t104 pfet_03v3 ad=2.08p pd=8.52u as=2.08p ps=8.52u w=8u l=0.28u
X64 VDD.t159 CLKP_HB.t15 a_2700_6400.t4 VDD.t158 pfet_03v3 ad=2.08p pd=8.52u as=3.52p ps=16.88u w=8u l=0.28u
X65 a_14540_6400.t18 a_6924_6400.t18 VSS.t167 VSS.t166 nfet_03v3 ad=2.08p pd=8.52u as=2.08p ps=8.52u w=8u l=0.28u
X66 a_2700_6400.t3 CLKP_HB.t4 VSS.t117 VSS.t116 nfet_03v3 ad=3.52p pd=16.88u as=2.08p ps=8.52u w=8u l=0.28u
X67 O_CAPTURE_CLKB.t11 a_2700_41600.t14 VSS.t129 VSS.t128 nfet_03v3 ad=2.08p pd=8.52u as=2.08p ps=8.52u w=8u l=0.28u
X68 O_SENSE.t7 a_14540_41600.t64 VDD.t27 VDD.t26 pfet_03v3 ad=2.08p pd=8.52u as=2.08p ps=8.52u w=8u l=0.28u
X69 VSS.t29 a_14540_41600.t27 O_SENSE.t14 VSS.t28 nfet_03v3 ad=2.08p pd=8.52u as=2.08p ps=8.52u w=8u l=0.28u
X70 VDD.t271 a_14540_6400.t53 E_SENSE.t39 VDD.t270 pfet_03v3 ad=2.08p pd=8.52u as=2.08p ps=8.52u w=8u l=0.28u
X71 E_CAPTURE_CLKB.t2 a_2700_6400.t20 VDD.t37 VDD.t36 pfet_03v3 ad=2.08p pd=8.52u as=2.08p ps=8.52u w=8u l=0.28u
X72 a_4812_6400.t3 CLKP_H.t0 VSS.t133 VSS.t132 nfet_03v3 ad=3.52p pd=16.88u as=2.08p ps=8.52u w=8u l=0.28u
X73 VDD.t203 a_14540_6400.t51 E_SENSE.t24 VDD.t202 pfet_03v3 ad=2.08p pd=8.52u as=2.08p ps=8.52u w=8u l=0.28u
X74 VDD.t125 a_14540_6400.t59 E_SENSE.t10 VDD.t124 pfet_03v3 ad=2.08p pd=8.52u as=2.08p ps=8.52u w=8u l=0.28u
X75 VDD.t195 a_4812_41600.t23 O_CAPTURE_CLK.t15 VDD.t194 pfet_03v3 ad=2.08p pd=8.52u as=3.52p ps=16.88u w=8u l=0.28u
X76 VDD.t53 a_14540_41600.t49 O_SENSE.t18 VDD.t52 pfet_03v3 ad=2.08p pd=8.52u as=2.08p ps=8.52u w=8u l=0.28u
X77 VSS.t199 a_14540_41600.t39 O_SENSE.t46 VSS.t198 nfet_03v3 ad=2.08p pd=8.52u as=3.52p ps=16.88u w=8u l=0.28u
X78 VSS.t19 a_2700_41600.t11 O_CAPTURE_CLKB.t0 VSS.t18 nfet_03v3 ad=2.08p pd=8.52u as=2.08p ps=8.52u w=8u l=0.28u
X79 VSS.t169 a_6924_6400.t19 a_14540_6400.t19 VSS.t168 nfet_03v3 ad=2.08p pd=8.52u as=3.52p ps=16.88u w=8u l=0.28u
X80 VSS.t115 CLKP_HB.t5 a_2700_6400.t2 VSS.t114 nfet_03v3 ad=2.08p pd=8.52u as=2.08p ps=8.52u w=8u l=0.28u
X81 VDD.t85 a_14540_41600.t61 O_SENSE.t23 VDD.t84 pfet_03v3 ad=2.08p pd=8.52u as=2.08p ps=8.52u w=8u l=0.28u
X82 O_SENSE.t41 a_14540_41600.t24 VSS.t83 VSS.t82 nfet_03v3 ad=3.52p pd=16.88u as=2.08p ps=8.52u w=8u l=0.28u
X83 VSS.t135 CLKP_H.t3 a_4812_6400.t0 VSS.t134 nfet_03v3 ad=2.08p pd=8.52u as=3.52p ps=16.88u w=8u l=0.28u
X84 O_SENSE.t43 a_14540_41600.t70 VDD.t173 VDD.t172 pfet_03v3 ad=2.08p pd=8.52u as=2.08p ps=8.52u w=8u l=0.28u
X85 VSS.t131 CLKP_H.t1 a_4812_6400.t2 VSS.t130 nfet_03v3 ad=2.08p pd=8.52u as=2.08p ps=8.52u w=8u l=0.28u
X86 VSS.t79 a_14540_41600.t33 O_SENSE.t39 VSS.t78 nfet_03v3 ad=2.08p pd=8.52u as=2.08p ps=8.52u w=8u l=0.28u
X87 a_4812_6400.t5 CLKP_H.t6 VDD.t209 VDD.t208 pfet_03v3 ad=2.08p pd=8.52u as=2.08p ps=8.52u w=8u l=0.28u
X88 a_2700_41600.t5 CLKN_HB.t14 VDD.t141 VDD.t140 pfet_03v3 ad=2.08p pd=8.52u as=2.08p ps=8.52u w=8u l=0.28u
X89 VDD.t277 a_6924_41600.t21 a_14540_41600.t16 VDD.t276 pfet_03v3 ad=2.08p pd=8.52u as=2.08p ps=8.52u w=8u l=0.28u
X90 VDD.t29 a_14540_41600.t55 O_SENSE.t8 VDD.t28 pfet_03v3 ad=2.08p pd=8.52u as=2.08p ps=8.52u w=8u l=0.28u
X91 VSS.t55 a_2700_6400.t9 E_CAPTURE_CLKB.t5 VSS.t54 nfet_03v3 ad=2.08p pd=8.52u as=2.08p ps=8.52u w=8u l=0.28u
X92 VDD.t261 a_14540_41600.t67 O_SENSE.t44 VDD.t260 pfet_03v3 ad=2.08p pd=8.52u as=2.08p ps=8.52u w=8u l=0.28u
X93 E_SENSE.t21 a_14540_6400.t44 VDD.t181 VDD.t180 pfet_03v3 ad=2.08p pd=8.52u as=2.08p ps=8.52u w=8u l=0.28u
X94 O_SENSE.t5 a_14540_41600.t30 VSS.t11 VSS.t10 nfet_03v3 ad=2.08p pd=8.52u as=2.08p ps=8.52u w=8u l=0.28u
X95 a_14540_6400.t2 a_6924_6400.t12 VSS.t75 VSS.t74 nfet_03v3 ad=2.08p pd=8.52u as=2.08p ps=8.52u w=8u l=0.28u
X96 a_14540_6400.t20 a_6924_6400.t10 VSS.t183 VSS.t182 nfet_03v3 ad=2.08p pd=8.52u as=2.08p ps=8.52u w=8u l=0.28u
X97 a_6924_6400.t1 CLKP_HB.t2 VSS.t119 VSS.t118 nfet_03v3 ad=2.08p pd=8.52u as=2.08p ps=8.52u w=8u l=0.28u
X98 VDD.t171 a_6924_6400.t25 a_14540_6400.t9 VDD.t170 pfet_03v3 ad=2.08p pd=8.52u as=2.08p ps=8.52u w=8u l=0.28u
X99 VDD.t243 a_6924_41600.t27 a_14540_41600.t6 VDD.t242 pfet_03v3 ad=2.08p pd=8.52u as=2.08p ps=8.52u w=8u l=0.28u
X100 VDD.t67 a_2700_41600.t17 O_CAPTURE_CLKB.t6 VDD.t66 pfet_03v3 ad=2.08p pd=8.52u as=2.08p ps=8.52u w=8u l=0.28u
X101 a_14540_41600.t3 a_6924_41600.t14 VSS.t143 VSS.t142 nfet_03v3 ad=2.08p pd=8.52u as=2.08p ps=8.52u w=8u l=0.28u
X102 VDD.t63 a_4812_41600.t21 O_CAPTURE_CLK.t9 VDD.t62 pfet_03v3 ad=2.08p pd=8.52u as=2.08p ps=8.52u w=8u l=0.28u
X103 O_CAPTURE_CLKB.t14 a_2700_41600.t8 VSS.t189 VSS.t188 nfet_03v3 ad=3.52p pd=16.88u as=2.08p ps=8.52u w=8u l=0.28u
X104 VSS.t109 CLKP_HB.t3 a_6924_6400.t0 VSS.t108 nfet_03v3 ad=2.08p pd=8.52u as=3.52p ps=16.88u w=8u l=0.28u
X105 a_14540_6400.t4 a_6924_6400.t26 VDD.t111 VDD.t110 pfet_03v3 ad=2.08p pd=8.52u as=2.08p ps=8.52u w=8u l=0.28u
X106 a_14540_41600.t7 a_6924_41600.t24 VDD.t245 VDD.t244 pfet_03v3 ad=2.08p pd=8.52u as=2.08p ps=8.52u w=8u l=0.28u
X107 O_CAPTURE_CLK.t0 a_4812_41600.t12 VSS.t15 VSS.t14 nfet_03v3 ad=2.08p pd=8.52u as=2.08p ps=8.52u w=8u l=0.28u
X108 VSS.t173 a_6924_41600.t11 a_14540_41600.t10 VSS.t172 nfet_03v3 ad=2.08p pd=8.52u as=2.08p ps=8.52u w=8u l=0.28u
X109 O_CAPTURE_CLK.t2 a_4812_41600.t18 VDD.t39 VDD.t38 pfet_03v3 ad=2.08p pd=8.52u as=2.08p ps=8.52u w=8u l=0.28u
X110 O_SENSE.t28 a_14540_41600.t44 VDD.t95 VDD.t94 pfet_03v3 ad=2.08p pd=8.52u as=2.08p ps=8.52u w=8u l=0.28u
X111 VSS.t209 a_14540_6400.t33 E_SENSE.t46 VSS.t208 nfet_03v3 ad=2.08p pd=8.52u as=2.08p ps=8.52u w=8u l=0.28u
X112 a_2700_41600.t7 CLKN_HB.t12 VDD.t145 VDD.t144 pfet_03v3 ad=3.52p pd=16.88u as=2.08p ps=8.52u w=8u l=0.28u
X113 a_4812_41600.t3 CLKN_H.t0 VSS.t151 VSS.t150 nfet_03v3 ad=3.52p pd=16.88u as=2.08p ps=8.52u w=8u l=0.28u
X114 a_14540_41600.t11 a_6924_41600.t30 VDD.t249 VDD.t248 pfet_03v3 ad=2.08p pd=8.52u as=2.08p ps=8.52u w=8u l=0.28u
X115 VSS.t53 a_4812_41600.t9 O_CAPTURE_CLK.t7 VSS.t52 nfet_03v3 ad=2.08p pd=8.52u as=2.08p ps=8.52u w=8u l=0.28u
X116 VDD.t119 a_14540_41600.t41 O_SENSE.t37 VDD.t118 pfet_03v3 ad=2.08p pd=8.52u as=2.08p ps=8.52u w=8u l=0.28u
X117 a_6924_41600.t3 CLKN_HB.t0 VSS.t107 VSS.t106 nfet_03v3 ad=3.52p pd=16.88u as=2.08p ps=8.52u w=8u l=0.28u
X118 O_SENSE.t15 a_14540_41600.t28 VSS.t31 VSS.t30 nfet_03v3 ad=2.08p pd=8.52u as=2.08p ps=8.52u w=8u l=0.28u
X119 VSS.t221 a_6924_41600.t17 a_14540_41600.t23 VSS.t220 nfet_03v3 ad=2.08p pd=8.52u as=2.08p ps=8.52u w=8u l=0.28u
X120 E_SENSE.t47 a_14540_6400.t34 VSS.t211 VSS.t210 nfet_03v3 ad=2.08p pd=8.52u as=2.08p ps=8.52u w=8u l=0.28u
X121 E_CAPTURE_CLK.t6 a_4812_6400.t10 VSS.t23 VSS.t22 nfet_03v3 ad=2.08p pd=8.52u as=2.08p ps=8.52u w=8u l=0.28u
X122 O_SENSE.t19 a_14540_41600.t50 VDD.t55 VDD.t54 pfet_03v3 ad=2.08p pd=8.52u as=2.08p ps=8.52u w=8u l=0.28u
X123 VDD.t219 a_14540_6400.t67 E_SENSE.t26 VDD.t218 pfet_03v3 ad=2.08p pd=8.52u as=2.08p ps=8.52u w=8u l=0.28u
X124 O_SENSE.t24 a_14540_41600.t62 VDD.t87 VDD.t86 pfet_03v3 ad=2.08p pd=8.52u as=2.08p ps=8.52u w=8u l=0.28u
X125 VSS.t49 a_4812_41600.t15 O_CAPTURE_CLK.t5 VSS.t48 nfet_03v3 ad=2.08p pd=8.52u as=3.52p ps=16.88u w=8u l=0.28u
X126 VSS.t71 a_14540_41600.t25 O_SENSE.t31 VSS.t70 nfet_03v3 ad=2.08p pd=8.52u as=2.08p ps=8.52u w=8u l=0.28u
X127 E_SENSE.t35 a_14540_6400.t26 VSS.t179 VSS.t178 nfet_03v3 ad=2.08p pd=8.52u as=2.08p ps=8.52u w=8u l=0.28u
X128 VSS.t45 a_2700_6400.t11 E_CAPTURE_CLKB.t4 VSS.t44 nfet_03v3 ad=2.08p pd=8.52u as=2.08p ps=8.52u w=8u l=0.28u
X129 VDD.t7 a_14540_41600.t47 O_SENSE.t2 VDD.t6 pfet_03v3 ad=2.08p pd=8.52u as=2.08p ps=8.52u w=8u l=0.28u
X130 VSS.t25 a_14540_41600.t37 O_SENSE.t12 VSS.t24 nfet_03v3 ad=2.08p pd=8.52u as=2.08p ps=8.52u w=8u l=0.28u
X131 VSS.t5 a_4812_6400.t11 E_CAPTURE_CLK.t0 VSS.t4 nfet_03v3 ad=2.08p pd=8.52u as=2.08p ps=8.52u w=8u l=0.28u
X132 E_CAPTURE_CLK.t15 a_4812_6400.t20 VDD.t259 VDD.t258 pfet_03v3 ad=2.08p pd=8.52u as=2.08p ps=8.52u w=8u l=0.28u
X133 VSS.t111 CLKP_HB.t7 a_2700_6400.t0 VSS.t110 nfet_03v3 ad=2.08p pd=8.52u as=3.52p ps=16.88u w=8u l=0.28u
X134 E_SENSE.t0 a_14540_6400.t68 VDD.t1 VDD.t0 pfet_03v3 ad=2.08p pd=8.52u as=2.08p ps=8.52u w=8u l=0.28u
X135 VDD.t143 CLKN_HB.t15 a_2700_41600.t4 VDD.t142 pfet_03v3 ad=2.08p pd=8.52u as=3.52p ps=16.88u w=8u l=0.28u
X136 a_14540_41600.t13 a_6924_41600.t22 VDD.t253 VDD.t252 pfet_03v3 ad=2.08p pd=8.52u as=2.08p ps=8.52u w=8u l=0.28u
X137 VDD.t49 a_14540_41600.t59 O_SENSE.t16 VDD.t48 pfet_03v3 ad=2.08p pd=8.52u as=2.08p ps=8.52u w=8u l=0.28u
X138 VSS.t201 a_14540_6400.t29 E_SENSE.t41 VSS.t200 nfet_03v3 ad=2.08p pd=8.52u as=2.08p ps=8.52u w=8u l=0.28u
X139 VSS.t59 a_14540_6400.t35 E_SENSE.t8 VSS.t58 nfet_03v3 ad=2.08p pd=8.52u as=2.08p ps=8.52u w=8u l=0.28u
X140 VDD.t137 CLKN_HB.t11 a_6924_41600.t4 VDD.t136 pfet_03v3 ad=2.08p pd=8.52u as=3.52p ps=16.88u w=8u l=0.28u
X141 a_2700_41600.t1 CLKN_HB.t6 VSS.t97 VSS.t96 nfet_03v3 ad=2.08p pd=8.52u as=2.08p ps=8.52u w=8u l=0.28u
X142 VSS.t89 a_14540_6400.t27 E_SENSE.t16 VSS.t88 nfet_03v3 ad=2.08p pd=8.52u as=2.08p ps=8.52u w=8u l=0.28u
X143 E_CAPTURE_CLKB.t14 a_2700_6400.t12 VSS.t207 VSS.t206 nfet_03v3 ad=2.08p pd=8.52u as=2.08p ps=8.52u w=8u l=0.28u
X144 E_SENSE.t40 a_14540_6400.t54 VDD.t273 VDD.t272 pfet_03v3 ad=2.08p pd=8.52u as=2.08p ps=8.52u w=8u l=0.28u
X145 VSS.t13 a_6924_41600.t9 a_14540_41600.t0 VSS.t12 nfet_03v3 ad=2.08p pd=8.52u as=2.08p ps=8.52u w=8u l=0.28u
X146 VSS.t39 a_14540_41600.t31 O_SENSE.t20 VSS.t38 nfet_03v3 ad=2.08p pd=8.52u as=2.08p ps=8.52u w=8u l=0.28u
X147 VDD.t11 a_2700_6400.t21 E_CAPTURE_CLKB.t0 VDD.t10 pfet_03v3 ad=2.08p pd=8.52u as=2.08p ps=8.52u w=8u l=0.28u
X148 E_SENSE.t25 a_14540_6400.t52 VDD.t205 VDD.t204 pfet_03v3 ad=2.08p pd=8.52u as=2.08p ps=8.52u w=8u l=0.28u
X149 E_SENSE.t11 a_14540_6400.t60 VDD.t127 VDD.t126 pfet_03v3 ad=2.08p pd=8.52u as=2.08p ps=8.52u w=8u l=0.28u
X150 VDD.t65 a_2700_41600.t23 O_CAPTURE_CLKB.t5 VDD.t64 pfet_03v3 ad=2.08p pd=8.52u as=3.52p ps=16.88u w=8u l=0.28u
X151 VDD.t107 a_14540_41600.t65 O_SENSE.t35 VDD.t106 pfet_03v3 ad=2.08p pd=8.52u as=2.08p ps=8.52u w=8u l=0.28u
X152 a_4812_6400.t1 CLKP_H.t2 VSS.t137 VSS.t136 nfet_03v3 ad=2.08p pd=8.52u as=2.08p ps=8.52u w=8u l=0.28u
X153 VDD.t15 a_14540_6400.t61 E_SENSE.t3 VDD.t14 pfet_03v3 ad=2.08p pd=8.52u as=2.08p ps=8.52u w=8u l=0.28u
X154 O_CAPTURE_CLKB.t10 a_2700_41600.t20 VDD.t199 VDD.t198 pfet_03v3 ad=2.08p pd=8.52u as=2.08p ps=8.52u w=8u l=0.28u
X155 VSS.t145 a_6924_41600.t15 a_14540_41600.t4 VSS.t144 nfet_03v3 ad=2.08p pd=8.52u as=2.08p ps=8.52u w=8u l=0.28u
X156 VSS.t193 a_2700_41600.t9 O_CAPTURE_CLKB.t15 VSS.t192 nfet_03v3 ad=2.08p pd=8.52u as=2.08p ps=8.52u w=8u l=0.28u
X157 VDD.t247 a_6924_41600.t25 a_14540_41600.t8 VDD.t246 pfet_03v3 ad=2.08p pd=8.52u as=2.08p ps=8.52u w=8u l=0.28u
X158 VDD.t281 a_14540_6400.t47 E_SENSE.t44 VDD.t280 pfet_03v3 ad=2.08p pd=8.52u as=2.08p ps=8.52u w=8u l=0.28u
X159 VDD.t129 a_14540_6400.t45 E_SENSE.t12 VDD.t128 pfet_03v3 ad=2.08p pd=8.52u as=2.08p ps=8.52u w=8u l=0.28u
X160 O_SENSE.t1 a_14540_41600.t58 VDD.t5 VDD.t4 pfet_03v3 ad=2.08p pd=8.52u as=2.08p ps=8.52u w=8u l=0.28u
X161 VSS.t17 a_4812_41600.t13 O_CAPTURE_CLK.t1 VSS.t16 nfet_03v3 ad=2.08p pd=8.52u as=2.08p ps=8.52u w=8u l=0.28u
X162 a_14540_41600.t20 a_6924_41600.t12 VSS.t215 VSS.t214 nfet_03v3 ad=2.08p pd=8.52u as=2.08p ps=8.52u w=8u l=0.28u
X163 VSS.t77 a_6924_6400.t13 a_14540_6400.t3 VSS.t76 nfet_03v3 ad=2.08p pd=8.52u as=2.08p ps=8.52u w=8u l=0.28u
X164 VDD.t233 CLKN_H.t7 a_4812_41600.t4 VDD.t232 pfet_03v3 ad=2.08p pd=8.52u as=3.52p ps=16.88u w=8u l=0.28u
X165 VDD.t33 a_14540_41600.t45 O_SENSE.t10 VDD.t32 pfet_03v3 ad=2.08p pd=8.52u as=2.08p ps=8.52u w=8u l=0.28u
X166 E_SENSE.t45 a_14540_6400.t48 VDD.t283 VDD.t282 pfet_03v3 ad=2.08p pd=8.52u as=2.08p ps=8.52u w=8u l=0.28u
X167 O_CAPTURE_CLK.t12 a_4812_41600.t10 VSS.t125 VSS.t124 nfet_03v3 ad=2.08p pd=8.52u as=2.08p ps=8.52u w=8u l=0.28u
X168 E_SENSE.t13 a_14540_6400.t46 VDD.t131 VDD.t130 pfet_03v3 ad=2.08p pd=8.52u as=2.08p ps=8.52u w=8u l=0.28u
X169 O_CAPTURE_CLK.t10 a_4812_41600.t16 VDD.t175 VDD.t174 pfet_03v3 ad=3.52p pd=16.88u as=2.08p ps=8.52u w=8u l=0.28u
X170 O_SENSE.t38 a_14540_41600.t42 VDD.t121 VDD.t120 pfet_03v3 ad=2.08p pd=8.52u as=2.08p ps=8.52u w=8u l=0.28u
X171 a_2700_41600.t3 CLKN_HB.t4 VSS.t101 VSS.t100 nfet_03v3 ad=3.52p pd=16.88u as=2.08p ps=8.52u w=8u l=0.28u
X172 VDD.t101 a_6924_6400.t29 a_14540_6400.t1 VDD.t100 pfet_03v3 ad=2.08p pd=8.52u as=2.08p ps=8.52u w=8u l=0.28u
X173 a_14540_6400.t14 a_6924_6400.t14 VSS.t159 VSS.t158 nfet_03v3 ad=2.08p pd=8.52u as=2.08p ps=8.52u w=8u l=0.28u
X174 E_SENSE.t37 a_14540_6400.t40 VDD.t265 VDD.t264 pfet_03v3 ad=3.52p pd=16.88u as=2.08p ps=8.52u w=8u l=0.28u
X175 a_14540_41600.t1 a_6924_41600.t18 VSS.t139 VSS.t138 nfet_03v3 ad=2.08p pd=8.52u as=2.08p ps=8.52u w=8u l=0.28u
X176 VDD.t113 a_6924_6400.t27 a_14540_6400.t5 VDD.t112 pfet_03v3 ad=2.08p pd=8.52u as=2.08p ps=8.52u w=8u l=0.28u
X177 O_SENSE.t32 a_14540_41600.t26 VSS.t73 VSS.t72 nfet_03v3 ad=2.08p pd=8.52u as=2.08p ps=8.52u w=8u l=0.28u
X178 a_14540_6400.t0 a_6924_6400.t28 VDD.t99 VDD.t98 pfet_03v3 ad=2.08p pd=8.52u as=2.08p ps=8.52u w=8u l=0.28u
X179 VDD.t229 a_14540_6400.t41 E_SENSE.t31 VDD.t228 pfet_03v3 ad=2.08p pd=8.52u as=2.08p ps=8.52u w=8u l=0.28u
X180 O_SENSE.t13 a_14540_41600.t38 VSS.t27 VSS.t26 nfet_03v3 ad=2.08p pd=8.52u as=2.08p ps=8.52u w=8u l=0.28u
X181 O_SENSE.t17 a_14540_41600.t60 VDD.t51 VDD.t50 pfet_03v3 ad=2.08p pd=8.52u as=2.08p ps=8.52u w=8u l=0.28u
X182 a_6924_6400.t7 CLKP_HB.t8 VDD.t149 VDD.t148 pfet_03v3 ad=3.52p pd=16.88u as=2.08p ps=8.52u w=8u l=0.28u
X183 a_14540_6400.t10 a_6924_6400.t20 VDD.t183 VDD.t182 pfet_03v3 ad=3.52p pd=16.88u as=2.08p ps=8.52u w=8u l=0.28u
X184 VSS.t95 CLKN_HB.t7 a_2700_41600.t0 VSS.t94 nfet_03v3 ad=2.08p pd=8.52u as=3.52p ps=16.88u w=8u l=0.28u
X185 a_14540_41600.t9 a_6924_41600.t10 VSS.t171 VSS.t170 nfet_03v3 ad=2.08p pd=8.52u as=2.08p ps=8.52u w=8u l=0.28u
X186 VSS.t67 a_14540_41600.t35 O_SENSE.t29 VSS.t66 nfet_03v3 ad=2.08p pd=8.52u as=2.08p ps=8.52u w=8u l=0.28u
X187 E_CAPTURE_CLKB.t10 a_2700_6400.t16 VDD.t217 VDD.t216 pfet_03v3 ad=3.52p pd=16.88u as=2.08p ps=8.52u w=8u l=0.28u
X188 VDD.t237 CLKN_H.t5 a_4812_41600.t6 VDD.t236 pfet_03v3 ad=2.08p pd=8.52u as=2.08p ps=8.52u w=8u l=0.28u
X189 a_14540_41600.t15 a_6924_41600.t20 VDD.t275 VDD.t274 pfet_03v3 ad=3.52p pd=16.88u as=2.08p ps=8.52u w=8u l=0.28u
X190 VSS.t93 CLKN_HB.t3 a_6924_41600.t0 VSS.t92 nfet_03v3 ad=2.08p pd=8.52u as=3.52p ps=16.88u w=8u l=0.28u
X191 VDD.t117 a_6924_6400.t23 a_14540_6400.t7 VDD.t116 pfet_03v3 ad=2.08p pd=8.52u as=2.08p ps=8.52u w=8u l=0.28u
X192 VDD.t147 CLKN_HB.t9 a_6924_41600.t6 VDD.t146 pfet_03v3 ad=2.08p pd=8.52u as=2.08p ps=8.52u w=8u l=0.28u
X193 VDD.t163 CLKP_HB.t9 a_6924_6400.t6 VDD.t162 pfet_03v3 ad=2.08p pd=8.52u as=2.08p ps=8.52u w=8u l=0.28u
X194 VDD.t185 a_6924_6400.t21 a_14540_6400.t11 VDD.t184 pfet_03v3 ad=2.08p pd=8.52u as=2.08p ps=8.52u w=8u l=0.28u
X195 VSS.t33 a_2700_41600.t15 O_CAPTURE_CLKB.t3 VSS.t32 nfet_03v3 ad=2.08p pd=8.52u as=3.52p ps=16.88u w=8u l=0.28u
X196 VDD.t19 a_4812_6400.t23 E_CAPTURE_CLK.t2 VDD.t18 pfet_03v3 ad=2.08p pd=8.52u as=3.52p ps=16.88u w=8u l=0.28u
X197 E_CAPTURE_CLK.t1 a_4812_6400.t12 VSS.t7 VSS.t6 nfet_03v3 ad=2.08p pd=8.52u as=2.08p ps=8.52u w=8u l=0.28u
X198 VDD.t43 a_2700_41600.t21 O_CAPTURE_CLKB.t1 VDD.t42 pfet_03v3 ad=2.08p pd=8.52u as=2.08p ps=8.52u w=8u l=0.28u
X199 VDD.t77 a_4812_6400.t21 E_CAPTURE_CLK.t9 VDD.t76 pfet_03v3 ad=2.08p pd=8.52u as=2.08p ps=8.52u w=8u l=0.28u
X200 VDD.t201 a_14540_6400.t69 E_SENSE.t23 VDD.t200 pfet_03v3 ad=2.08p pd=8.52u as=2.08p ps=8.52u w=8u l=0.28u
X201 O_CAPTURE_CLKB.t12 a_2700_41600.t12 VSS.t181 VSS.t180 nfet_03v3 ad=2.08p pd=8.52u as=2.08p ps=8.52u w=8u l=0.28u
X202 E_SENSE.t42 a_14540_6400.t30 VSS.t203 VSS.t202 nfet_03v3 ad=2.08p pd=8.52u as=2.08p ps=8.52u w=8u l=0.28u
X203 E_SENSE.t9 a_14540_6400.t36 VSS.t61 VSS.t60 nfet_03v3 ad=2.08p pd=8.52u as=2.08p ps=8.52u w=8u l=0.28u
X204 E_SENSE.t17 a_14540_6400.t28 VSS.t91 VSS.t90 nfet_03v3 ad=2.08p pd=8.52u as=2.08p ps=8.52u w=8u l=0.28u
X205 VSS.t205 a_2700_6400.t13 E_CAPTURE_CLKB.t13 VSS.t204 nfet_03v3 ad=2.08p pd=8.52u as=2.08p ps=8.52u w=8u l=0.28u
X206 VDD.t225 a_14540_6400.t55 E_SENSE.t29 VDD.t224 pfet_03v3 ad=2.08p pd=8.52u as=2.08p ps=8.52u w=8u l=0.28u
X207 O_CAPTURE_CLKB.t7 a_2700_41600.t18 VDD.t69 VDD.t68 pfet_03v3 ad=2.08p pd=8.52u as=2.08p ps=8.52u w=8u l=0.28u
X208 VSS.t217 a_6924_41600.t13 a_14540_41600.t21 VSS.t216 nfet_03v3 ad=2.08p pd=8.52u as=2.08p ps=8.52u w=8u l=0.28u
X209 E_CAPTURE_CLKB.t8 a_2700_6400.t22 VDD.t97 VDD.t96 pfet_03v3 ad=2.08p pd=8.52u as=2.08p ps=8.52u w=8u l=0.28u
X210 VDD.t83 a_14540_41600.t71 O_SENSE.t22 VDD.t82 pfet_03v3 ad=2.08p pd=8.52u as=3.52p ps=16.88u w=8u l=0.28u
X211 E_CAPTURE_CLK.t10 a_4812_6400.t22 VDD.t79 VDD.t78 pfet_03v3 ad=2.08p pd=8.52u as=2.08p ps=8.52u w=8u l=0.28u
X212 O_SENSE.t40 a_14540_41600.t34 VSS.t81 VSS.t80 nfet_03v3 ad=2.08p pd=8.52u as=2.08p ps=8.52u w=8u l=0.28u
X213 VSS.t153 CLKN_H.t3 a_4812_41600.t0 VSS.t152 nfet_03v3 ad=2.08p pd=8.52u as=3.52p ps=16.88u w=8u l=0.28u
X214 E_CAPTURE_CLK.t12 a_4812_6400.t16 VDD.t81 VDD.t80 pfet_03v3 ad=3.52p pd=16.88u as=2.08p ps=8.52u w=8u l=0.28u
X215 VSS.t1 a_14540_6400.t37 E_SENSE.t1 VSS.t0 nfet_03v3 ad=2.08p pd=8.52u as=2.08p ps=8.52u w=8u l=0.28u
X216 O_SENSE.t9 a_14540_41600.t56 VDD.t31 VDD.t30 pfet_03v3 ad=2.08p pd=8.52u as=2.08p ps=8.52u w=8u l=0.28u
X217 E_SENSE.t30 a_14540_6400.t56 VDD.t227 VDD.t226 pfet_03v3 ad=2.08p pd=8.52u as=2.08p ps=8.52u w=8u l=0.28u
X218 O_SENSE.t45 a_14540_41600.t68 VDD.t263 VDD.t262 pfet_03v3 ad=2.08p pd=8.52u as=2.08p ps=8.52u w=8u l=0.28u
X219 VDD.t215 a_2700_6400.t23 E_CAPTURE_CLKB.t9 VDD.t214 pfet_03v3 ad=2.08p pd=8.52u as=3.52p ps=16.88u w=8u l=0.28u
X220 E_SENSE.t4 a_14540_6400.t62 VDD.t17 VDD.t16 pfet_03v3 ad=2.08p pd=8.52u as=2.08p ps=8.52u w=8u l=0.28u
X221 O_CAPTURE_CLK.t6 a_4812_41600.t8 VSS.t51 VSS.t50 nfet_03v3 ad=3.52p pd=16.88u as=2.08p ps=8.52u w=8u l=0.28u
X222 VDD.t89 a_14540_41600.t53 O_SENSE.t25 VDD.t88 pfet_03v3 ad=2.08p pd=8.52u as=2.08p ps=8.52u w=8u l=0.28u
X223 VDD.t21 a_4812_6400.t17 E_CAPTURE_CLK.t3 VDD.t20 pfet_03v3 ad=2.08p pd=8.52u as=2.08p ps=8.52u w=8u l=0.28u
X224 O_SENSE.t47 a_14540_41600.t40 VDD.t267 VDD.t266 pfet_03v3 ad=3.52p pd=16.88u as=2.08p ps=8.52u w=8u l=0.28u
X225 a_14540_41600.t18 a_6924_41600.t28 VDD.t285 VDD.t284 pfet_03v3 ad=2.08p pd=8.52u as=2.08p ps=8.52u w=8u l=0.28u
X226 VDD.t57 a_14540_6400.t63 E_SENSE.t5 VDD.t56 pfet_03v3 ad=2.08p pd=8.52u as=2.08p ps=8.52u w=8u l=0.28u
X227 E_SENSE.t33 a_14540_6400.t24 VSS.t157 VSS.t156 nfet_03v3 ad=3.52p pd=16.88u as=2.08p ps=8.52u w=8u l=0.28u
X228 E_CAPTURE_CLKB.t6 a_2700_6400.t18 VDD.t73 VDD.t72 pfet_03v3 ad=2.08p pd=8.52u as=2.08p ps=8.52u w=8u l=0.28u
X229 VDD.t221 a_14540_6400.t49 E_SENSE.t27 VDD.t220 pfet_03v3 ad=2.08p pd=8.52u as=2.08p ps=8.52u w=8u l=0.28u
X230 O_CAPTURE_CLK.t14 a_4812_41600.t22 VDD.t193 VDD.t192 pfet_03v3 ad=2.08p pd=8.52u as=2.08p ps=8.52u w=8u l=0.28u
X231 a_2700_6400.t5 CLKP_HB.t14 VDD.t155 VDD.t154 pfet_03v3 ad=2.08p pd=8.52u as=2.08p ps=8.52u w=8u l=0.28u
X232 VSS.t165 a_6924_6400.t17 a_14540_6400.t17 VSS.t164 nfet_03v3 ad=2.08p pd=8.52u as=2.08p ps=8.52u w=8u l=0.28u
X233 a_2700_6400.t7 CLKP_HB.t12 VDD.t161 VDD.t160 pfet_03v3 ad=3.52p pd=16.88u as=2.08p ps=8.52u w=8u l=0.28u
X234 a_14540_6400.t12 a_6924_6400.t30 VDD.t189 VDD.t188 pfet_03v3 ad=2.08p pd=8.52u as=2.08p ps=8.52u w=8u l=0.28u
X235 VSS.t161 a_6924_6400.t15 a_14540_6400.t15 VSS.t160 nfet_03v3 ad=2.08p pd=8.52u as=2.08p ps=8.52u w=8u l=0.28u
X236 O_SENSE.t30 a_14540_41600.t36 VSS.t69 VSS.t68 nfet_03v3 ad=2.08p pd=8.52u as=2.08p ps=8.52u w=8u l=0.28u
X237 a_4812_41600.t5 CLKN_H.t6 VDD.t235 VDD.t234 pfet_03v3 ad=2.08p pd=8.52u as=2.08p ps=8.52u w=8u l=0.28u
X238 VDD.t41 a_4812_41600.t19 O_CAPTURE_CLK.t3 VDD.t40 pfet_03v3 ad=2.08p pd=8.52u as=2.08p ps=8.52u w=8u l=0.28u
X239 a_4812_6400.t7 CLKP_H.t4 VDD.t213 VDD.t212 pfet_03v3 ad=3.52p pd=16.88u as=2.08p ps=8.52u w=8u l=0.28u
X240 VSS.t147 CLKN_H.t1 a_4812_41600.t2 VSS.t146 nfet_03v3 ad=2.08p pd=8.52u as=2.08p ps=8.52u w=8u l=0.28u
X241 VDD.t139 CLKN_HB.t13 a_2700_41600.t6 VDD.t138 pfet_03v3 ad=2.08p pd=8.52u as=2.08p ps=8.52u w=8u l=0.28u
X242 a_6924_41600.t5 CLKN_HB.t10 VDD.t135 VDD.t134 pfet_03v3 ad=2.08p pd=8.52u as=2.08p ps=8.52u w=8u l=0.28u
X243 a_14540_41600.t17 a_6924_41600.t8 VSS.t213 VSS.t212 nfet_03v3 ad=3.52p pd=16.88u as=2.08p ps=8.52u w=8u l=0.28u
X244 VDD.t157 CLKP_HB.t13 a_2700_6400.t6 VDD.t156 pfet_03v3 ad=2.08p pd=8.52u as=2.08p ps=8.52u w=8u l=0.28u
X245 VDD.t191 a_6924_6400.t31 a_14540_6400.t13 VDD.t190 pfet_03v3 ad=2.08p pd=8.52u as=3.52p ps=16.88u w=8u l=0.28u
X246 a_14540_6400.t16 a_6924_6400.t16 VSS.t163 VSS.t162 nfet_03v3 ad=2.08p pd=8.52u as=2.08p ps=8.52u w=8u l=0.28u
X247 VDD.t251 a_6924_41600.t31 a_14540_41600.t12 VDD.t250 pfet_03v3 ad=2.08p pd=8.52u as=3.52p ps=16.88u w=8u l=0.28u
X248 E_SENSE.t32 a_14540_6400.t42 VDD.t231 VDD.t230 pfet_03v3 ad=2.08p pd=8.52u as=2.08p ps=8.52u w=8u l=0.28u
X249 VSS.t105 CLKN_HB.t1 a_6924_41600.t2 VSS.t104 nfet_03v3 ad=2.08p pd=8.52u as=2.08p ps=8.52u w=8u l=0.28u
X250 VDD.t207 CLKP_H.t7 a_4812_6400.t4 VDD.t206 pfet_03v3 ad=2.08p pd=8.52u as=3.52p ps=16.88u w=8u l=0.28u
X251 O_CAPTURE_CLKB.t2 a_2700_41600.t22 VDD.t45 VDD.t44 pfet_03v3 ad=2.08p pd=8.52u as=2.08p ps=8.52u w=8u l=0.28u
X252 VDD.t211 CLKP_H.t5 a_4812_6400.t6 VDD.t210 pfet_03v3 ad=2.08p pd=8.52u as=2.08p ps=8.52u w=8u l=0.28u
X253 VDD.t103 a_14540_41600.t51 O_SENSE.t33 VDD.t102 pfet_03v3 ad=2.08p pd=8.52u as=2.08p ps=8.52u w=8u l=0.28u
X254 a_14540_6400.t23 a_6924_6400.t8 VSS.t197 VSS.t196 nfet_03v3 ad=3.52p pd=16.88u as=2.08p ps=8.52u w=8u l=0.28u
X255 a_6924_6400.t3 CLKP_HB.t0 VSS.t123 VSS.t122 nfet_03v3 ad=3.52p pd=16.88u as=2.08p ps=8.52u w=8u l=0.28u
R0 E_SENSE.n46 E_SENSE.n30 13.6379
R1 E_SENSE.n46 E_SENSE.n45 10.4767
R2 E_SENSE.n32 E_SENSE.t33 5.7796
R3 E_SENSE.n1 E_SENSE.t37 5.73764
R4 E_SENSE.n45 E_SENSE.t36 5.59012
R5 E_SENSE.n30 E_SENSE.t22 5.54817
R6 E_SENSE.n32 E_SENSE.n31 5.38537
R7 E_SENSE.n34 E_SENSE.n33 5.38537
R8 E_SENSE.n36 E_SENSE.n35 5.38537
R9 E_SENSE.n38 E_SENSE.n37 5.38537
R10 E_SENSE.n40 E_SENSE.n39 5.38537
R11 E_SENSE.n42 E_SENSE.n41 5.38537
R12 E_SENSE.n44 E_SENSE.n43 5.38537
R13 E_SENSE.n1 E_SENSE.n0 5.32067
R14 E_SENSE.n3 E_SENSE.n2 5.32067
R15 E_SENSE.n5 E_SENSE.n4 5.32067
R16 E_SENSE.n7 E_SENSE.n6 5.32067
R17 E_SENSE.n9 E_SENSE.n8 5.32067
R18 E_SENSE.n11 E_SENSE.n10 5.32067
R19 E_SENSE.n13 E_SENSE.n12 5.32067
R20 E_SENSE.n15 E_SENSE.n14 5.32067
R21 E_SENSE.n17 E_SENSE.n16 5.32067
R22 E_SENSE.n19 E_SENSE.n18 5.32067
R23 E_SENSE.n21 E_SENSE.n20 5.32067
R24 E_SENSE.n23 E_SENSE.n22 5.32067
R25 E_SENSE.n25 E_SENSE.n24 5.32067
R26 E_SENSE.n27 E_SENSE.n26 5.32067
R27 E_SENSE.n29 E_SENSE.n28 5.32067
R28 E_SENSE E_SENSE.n46 4.61985
R29 E_SENSE.n0 E_SENSE.t32 0.228
R30 E_SENSE.n0 E_SENSE.t31 0.228
R31 E_SENSE.n2 E_SENSE.t21 0.228
R32 E_SENSE.n2 E_SENSE.t20 0.228
R33 E_SENSE.n4 E_SENSE.t13 0.228
R34 E_SENSE.n4 E_SENSE.t12 0.228
R35 E_SENSE.n6 E_SENSE.t45 0.228
R36 E_SENSE.n6 E_SENSE.t44 0.228
R37 E_SENSE.n8 E_SENSE.t28 0.228
R38 E_SENSE.n8 E_SENSE.t27 0.228
R39 E_SENSE.n10 E_SENSE.t25 0.228
R40 E_SENSE.n10 E_SENSE.t24 0.228
R41 E_SENSE.n12 E_SENSE.t40 0.228
R42 E_SENSE.n12 E_SENSE.t39 0.228
R43 E_SENSE.n14 E_SENSE.t30 0.228
R44 E_SENSE.n14 E_SENSE.t29 0.228
R45 E_SENSE.n16 E_SENSE.t19 0.228
R46 E_SENSE.n16 E_SENSE.t18 0.228
R47 E_SENSE.n18 E_SENSE.t11 0.228
R48 E_SENSE.n18 E_SENSE.t10 0.228
R49 E_SENSE.n20 E_SENSE.t4 0.228
R50 E_SENSE.n20 E_SENSE.t3 0.228
R51 E_SENSE.n22 E_SENSE.t6 0.228
R52 E_SENSE.n22 E_SENSE.t5 0.228
R53 E_SENSE.n24 E_SENSE.t7 0.228
R54 E_SENSE.n24 E_SENSE.t43 0.228
R55 E_SENSE.n26 E_SENSE.t0 0.228
R56 E_SENSE.n26 E_SENSE.t26 0.228
R57 E_SENSE.n28 E_SENSE.t38 0.228
R58 E_SENSE.n28 E_SENSE.t23 0.228
R59 E_SENSE.n31 E_SENSE.t35 0.20525
R60 E_SENSE.n31 E_SENSE.t34 0.20525
R61 E_SENSE.n33 E_SENSE.t17 0.20525
R62 E_SENSE.n33 E_SENSE.t16 0.20525
R63 E_SENSE.n35 E_SENSE.t42 0.20525
R64 E_SENSE.n35 E_SENSE.t41 0.20525
R65 E_SENSE.n37 E_SENSE.t15 0.20525
R66 E_SENSE.n37 E_SENSE.t14 0.20525
R67 E_SENSE.n39 E_SENSE.t47 0.20525
R68 E_SENSE.n39 E_SENSE.t46 0.20525
R69 E_SENSE.n41 E_SENSE.t9 0.20525
R70 E_SENSE.n41 E_SENSE.t8 0.20525
R71 E_SENSE.n43 E_SENSE.t2 0.20525
R72 E_SENSE.n43 E_SENSE.t1 0.20525
R73 E_SENSE.n30 E_SENSE.n29 0.189974
R74 E_SENSE.n29 E_SENSE.n27 0.189974
R75 E_SENSE.n27 E_SENSE.n25 0.189974
R76 E_SENSE.n25 E_SENSE.n23 0.189974
R77 E_SENSE.n23 E_SENSE.n21 0.189974
R78 E_SENSE.n21 E_SENSE.n19 0.189974
R79 E_SENSE.n19 E_SENSE.n17 0.189974
R80 E_SENSE.n17 E_SENSE.n15 0.189974
R81 E_SENSE.n15 E_SENSE.n13 0.189974
R82 E_SENSE.n13 E_SENSE.n11 0.189974
R83 E_SENSE.n11 E_SENSE.n9 0.189974
R84 E_SENSE.n9 E_SENSE.n7 0.189974
R85 E_SENSE.n7 E_SENSE.n5 0.189974
R86 E_SENSE.n5 E_SENSE.n3 0.189974
R87 E_SENSE.n3 E_SENSE.n1 0.189974
R88 E_SENSE.n45 E_SENSE.n44 0.189974
R89 E_SENSE.n44 E_SENSE.n42 0.189974
R90 E_SENSE.n42 E_SENSE.n40 0.189974
R91 E_SENSE.n40 E_SENSE.n38 0.189974
R92 E_SENSE.n38 E_SENSE.n36 0.189974
R93 E_SENSE.n36 E_SENSE.n34 0.189974
R94 E_SENSE.n34 E_SENSE.n32 0.189974
R95 E_CAPTURE_CLK E_CAPTURE_CLK.n14 7.98157
R96 E_CAPTURE_CLK.n14 E_CAPTURE_CLK.n6 6.5392
R97 E_CAPTURE_CLK.n8 E_CAPTURE_CLK.t13 5.7796
R98 E_CAPTURE_CLK.n1 E_CAPTURE_CLK.t12 5.73764
R99 E_CAPTURE_CLK.n13 E_CAPTURE_CLK.t11 5.59012
R100 E_CAPTURE_CLK.n6 E_CAPTURE_CLK.t2 5.54817
R101 E_CAPTURE_CLK.n8 E_CAPTURE_CLK.n7 5.38537
R102 E_CAPTURE_CLK.n10 E_CAPTURE_CLK.n9 5.38537
R103 E_CAPTURE_CLK.n12 E_CAPTURE_CLK.n11 5.38537
R104 E_CAPTURE_CLK.n1 E_CAPTURE_CLK.n0 5.32067
R105 E_CAPTURE_CLK.n3 E_CAPTURE_CLK.n2 5.32067
R106 E_CAPTURE_CLK.n5 E_CAPTURE_CLK.n4 5.32067
R107 E_CAPTURE_CLK.n14 E_CAPTURE_CLK.n13 4.61063
R108 E_CAPTURE_CLK.n0 E_CAPTURE_CLK.t4 0.228
R109 E_CAPTURE_CLK.n0 E_CAPTURE_CLK.t3 0.228
R110 E_CAPTURE_CLK.n2 E_CAPTURE_CLK.t15 0.228
R111 E_CAPTURE_CLK.n2 E_CAPTURE_CLK.t14 0.228
R112 E_CAPTURE_CLK.n4 E_CAPTURE_CLK.t10 0.228
R113 E_CAPTURE_CLK.n4 E_CAPTURE_CLK.t9 0.228
R114 E_CAPTURE_CLK.n7 E_CAPTURE_CLK.t6 0.20525
R115 E_CAPTURE_CLK.n7 E_CAPTURE_CLK.t5 0.20525
R116 E_CAPTURE_CLK.n9 E_CAPTURE_CLK.t1 0.20525
R117 E_CAPTURE_CLK.n9 E_CAPTURE_CLK.t0 0.20525
R118 E_CAPTURE_CLK.n11 E_CAPTURE_CLK.t8 0.20525
R119 E_CAPTURE_CLK.n11 E_CAPTURE_CLK.t7 0.20525
R120 E_CAPTURE_CLK.n13 E_CAPTURE_CLK.n12 0.189974
R121 E_CAPTURE_CLK.n12 E_CAPTURE_CLK.n10 0.189974
R122 E_CAPTURE_CLK.n10 E_CAPTURE_CLK.n8 0.189974
R123 E_CAPTURE_CLK.n6 E_CAPTURE_CLK.n5 0.189974
R124 E_CAPTURE_CLK.n5 E_CAPTURE_CLK.n3 0.189974
R125 E_CAPTURE_CLK.n3 E_CAPTURE_CLK.n1 0.189974
R126 E_CAPTURE_CLKB E_CAPTURE_CLKB.n14 6.63157
R127 E_CAPTURE_CLKB.n14 E_CAPTURE_CLKB.n6 6.5392
R128 E_CAPTURE_CLKB.n8 E_CAPTURE_CLKB.t11 5.7796
R129 E_CAPTURE_CLKB.n1 E_CAPTURE_CLKB.t10 5.73764
R130 E_CAPTURE_CLKB.n13 E_CAPTURE_CLKB.t12 5.59012
R131 E_CAPTURE_CLKB.n6 E_CAPTURE_CLKB.t9 5.54817
R132 E_CAPTURE_CLKB.n8 E_CAPTURE_CLKB.n7 5.38537
R133 E_CAPTURE_CLKB.n10 E_CAPTURE_CLKB.n9 5.38537
R134 E_CAPTURE_CLKB.n12 E_CAPTURE_CLKB.n11 5.38537
R135 E_CAPTURE_CLKB.n1 E_CAPTURE_CLKB.n0 5.32067
R136 E_CAPTURE_CLKB.n3 E_CAPTURE_CLKB.n2 5.32067
R137 E_CAPTURE_CLKB.n5 E_CAPTURE_CLKB.n4 5.32067
R138 E_CAPTURE_CLKB.n14 E_CAPTURE_CLKB.n13 4.61063
R139 E_CAPTURE_CLKB.n0 E_CAPTURE_CLKB.t6 0.228
R140 E_CAPTURE_CLKB.n0 E_CAPTURE_CLKB.t7 0.228
R141 E_CAPTURE_CLKB.n2 E_CAPTURE_CLKB.t2 0.228
R142 E_CAPTURE_CLKB.n2 E_CAPTURE_CLKB.t1 0.228
R143 E_CAPTURE_CLKB.n4 E_CAPTURE_CLKB.t8 0.228
R144 E_CAPTURE_CLKB.n4 E_CAPTURE_CLKB.t0 0.228
R145 E_CAPTURE_CLKB.n7 E_CAPTURE_CLKB.t15 0.20525
R146 E_CAPTURE_CLKB.n7 E_CAPTURE_CLKB.t5 0.20525
R147 E_CAPTURE_CLKB.n9 E_CAPTURE_CLKB.t14 0.20525
R148 E_CAPTURE_CLKB.n9 E_CAPTURE_CLKB.t4 0.20525
R149 E_CAPTURE_CLKB.n11 E_CAPTURE_CLKB.t3 0.20525
R150 E_CAPTURE_CLKB.n11 E_CAPTURE_CLKB.t13 0.20525
R151 E_CAPTURE_CLKB.n13 E_CAPTURE_CLKB.n12 0.189974
R152 E_CAPTURE_CLKB.n12 E_CAPTURE_CLKB.n10 0.189974
R153 E_CAPTURE_CLKB.n10 E_CAPTURE_CLKB.n8 0.189974
R154 E_CAPTURE_CLKB.n6 E_CAPTURE_CLKB.n5 0.189974
R155 E_CAPTURE_CLKB.n5 E_CAPTURE_CLKB.n3 0.189974
R156 E_CAPTURE_CLKB.n3 E_CAPTURE_CLKB.n1 0.189974
R157 CLKP_H.n8 CLKP_H.t3 113.632
R158 CLKP_H.n5 CLKP_H.t0 113.632
R159 CLKP_H.n0 CLKP_H.t4 113.632
R160 CLKP_H.n3 CLKP_H.t7 113.632
R161 CLKP_H.n6 CLKP_H.t1 109.174
R162 CLKP_H.n7 CLKP_H.t2 109.174
R163 CLKP_H.n1 CLKP_H.t5 109.174
R164 CLKP_H.n2 CLKP_H.t6 109.174
R165 CLKP_H CLKP_H.n10 15.3874
R166 CLKP_H.n7 CLKP_H.n6 11.6805
R167 CLKP_H.n2 CLKP_H.n1 11.6805
R168 CLKP_H.n10 CLKP_H.n4 10.9291
R169 CLKP_H.n10 CLKP_H.n9 9.0005
R170 CLKP_H.n9 CLKP_H.n5 7.10487
R171 CLKP_H.n9 CLKP_H.n8 7.10487
R172 CLKP_H.n4 CLKP_H.n0 7.10487
R173 CLKP_H.n4 CLKP_H.n3 7.10487
R174 CLKP_H.n6 CLKP_H.n5 4.42851
R175 CLKP_H.n8 CLKP_H.n7 4.42851
R176 CLKP_H.n1 CLKP_H.n0 4.42851
R177 CLKP_H.n3 CLKP_H.n2 4.42851
R178 CLKP_HB.n8 CLKP_HB.t3 113.632
R179 CLKP_HB.n5 CLKP_HB.t0 113.632
R180 CLKP_HB.n3 CLKP_HB.t11 113.632
R181 CLKP_HB.n0 CLKP_HB.t8 113.632
R182 CLKP_HB.n19 CLKP_HB.t7 113.632
R183 CLKP_HB.n16 CLKP_HB.t4 113.632
R184 CLKP_HB.n11 CLKP_HB.t12 113.632
R185 CLKP_HB.n14 CLKP_HB.t15 113.632
R186 CLKP_HB.n6 CLKP_HB.t1 109.174
R187 CLKP_HB.n7 CLKP_HB.t2 109.174
R188 CLKP_HB.n1 CLKP_HB.t9 109.174
R189 CLKP_HB.n2 CLKP_HB.t10 109.174
R190 CLKP_HB.n17 CLKP_HB.t5 109.174
R191 CLKP_HB.n18 CLKP_HB.t6 109.174
R192 CLKP_HB.n12 CLKP_HB.t13 109.174
R193 CLKP_HB.n13 CLKP_HB.t14 109.174
R194 CLKP_HB.n7 CLKP_HB.n6 11.6805
R195 CLKP_HB.n2 CLKP_HB.n1 11.6805
R196 CLKP_HB.n18 CLKP_HB.n17 11.6805
R197 CLKP_HB.n13 CLKP_HB.n12 11.6805
R198 CLKP_HB.n10 CLKP_HB.n4 10.9291
R199 CLKP_HB.n21 CLKP_HB.n15 10.9291
R200 CLKP_HB.n10 CLKP_HB.n9 9.0005
R201 CLKP_HB.n21 CLKP_HB.n20 9.0005
R202 CLKP_HB.n22 CLKP_HB.n10 8.70954
R203 CLKP_HB CLKP_HB.n22 8.25354
R204 CLKP_HB.n9 CLKP_HB.n5 7.10487
R205 CLKP_HB.n9 CLKP_HB.n8 7.10487
R206 CLKP_HB.n4 CLKP_HB.n0 7.10487
R207 CLKP_HB.n4 CLKP_HB.n3 7.10487
R208 CLKP_HB.n20 CLKP_HB.n16 7.10487
R209 CLKP_HB.n20 CLKP_HB.n19 7.10487
R210 CLKP_HB.n15 CLKP_HB.n11 7.10487
R211 CLKP_HB.n15 CLKP_HB.n14 7.10487
R212 CLKP_HB.n22 CLKP_HB.n21 4.59693
R213 CLKP_HB.n6 CLKP_HB.n5 4.42851
R214 CLKP_HB.n8 CLKP_HB.n7 4.42851
R215 CLKP_HB.n1 CLKP_HB.n0 4.42851
R216 CLKP_HB.n3 CLKP_HB.n2 4.42851
R217 CLKP_HB.n17 CLKP_HB.n16 4.42851
R218 CLKP_HB.n19 CLKP_HB.n18 4.42851
R219 CLKP_HB.n12 CLKP_HB.n11 4.42851
R220 CLKP_HB.n14 CLKP_HB.n13 4.42851
R221 O_SENSE.n46 O_SENSE.n30 13.6379
R222 O_SENSE.n46 O_SENSE.n45 10.4767
R223 O_SENSE.n32 O_SENSE.t41 5.7796
R224 O_SENSE.n1 O_SENSE.t47 5.73764
R225 O_SENSE.n45 O_SENSE.t46 5.59012
R226 O_SENSE.n30 O_SENSE.t22 5.54817
R227 O_SENSE.n32 O_SENSE.n31 5.38537
R228 O_SENSE.n34 O_SENSE.n33 5.38537
R229 O_SENSE.n36 O_SENSE.n35 5.38537
R230 O_SENSE.n38 O_SENSE.n37 5.38537
R231 O_SENSE.n40 O_SENSE.n39 5.38537
R232 O_SENSE.n42 O_SENSE.n41 5.38537
R233 O_SENSE.n44 O_SENSE.n43 5.38537
R234 O_SENSE.n1 O_SENSE.n0 5.32067
R235 O_SENSE.n3 O_SENSE.n2 5.32067
R236 O_SENSE.n5 O_SENSE.n4 5.32067
R237 O_SENSE.n7 O_SENSE.n6 5.32067
R238 O_SENSE.n9 O_SENSE.n8 5.32067
R239 O_SENSE.n11 O_SENSE.n10 5.32067
R240 O_SENSE.n13 O_SENSE.n12 5.32067
R241 O_SENSE.n15 O_SENSE.n14 5.32067
R242 O_SENSE.n17 O_SENSE.n16 5.32067
R243 O_SENSE.n19 O_SENSE.n18 5.32067
R244 O_SENSE.n21 O_SENSE.n20 5.32067
R245 O_SENSE.n23 O_SENSE.n22 5.32067
R246 O_SENSE.n25 O_SENSE.n24 5.32067
R247 O_SENSE.n27 O_SENSE.n26 5.32067
R248 O_SENSE.n29 O_SENSE.n28 5.32067
R249 O_SENSE O_SENSE.n46 4.61985
R250 O_SENSE.n0 O_SENSE.t38 0.228
R251 O_SENSE.n0 O_SENSE.t37 0.228
R252 O_SENSE.n2 O_SENSE.t28 0.228
R253 O_SENSE.n2 O_SENSE.t27 0.228
R254 O_SENSE.n4 O_SENSE.t11 0.228
R255 O_SENSE.n4 O_SENSE.t10 0.228
R256 O_SENSE.n6 O_SENSE.t3 0.228
R257 O_SENSE.n6 O_SENSE.t2 0.228
R258 O_SENSE.n8 O_SENSE.t19 0.228
R259 O_SENSE.n8 O_SENSE.t18 0.228
R260 O_SENSE.n10 O_SENSE.t34 0.228
R261 O_SENSE.n10 O_SENSE.t33 0.228
R262 O_SENSE.n12 O_SENSE.t26 0.228
R263 O_SENSE.n12 O_SENSE.t25 0.228
R264 O_SENSE.n14 O_SENSE.t9 0.228
R265 O_SENSE.n14 O_SENSE.t8 0.228
R266 O_SENSE.n16 O_SENSE.t1 0.228
R267 O_SENSE.n16 O_SENSE.t0 0.228
R268 O_SENSE.n18 O_SENSE.t17 0.228
R269 O_SENSE.n18 O_SENSE.t16 0.228
R270 O_SENSE.n20 O_SENSE.t24 0.228
R271 O_SENSE.n20 O_SENSE.t23 0.228
R272 O_SENSE.n22 O_SENSE.t7 0.228
R273 O_SENSE.n22 O_SENSE.t6 0.228
R274 O_SENSE.n24 O_SENSE.t36 0.228
R275 O_SENSE.n24 O_SENSE.t35 0.228
R276 O_SENSE.n26 O_SENSE.t45 0.228
R277 O_SENSE.n26 O_SENSE.t44 0.228
R278 O_SENSE.n28 O_SENSE.t43 0.228
R279 O_SENSE.n28 O_SENSE.t42 0.228
R280 O_SENSE.n31 O_SENSE.t32 0.20525
R281 O_SENSE.n31 O_SENSE.t31 0.20525
R282 O_SENSE.n33 O_SENSE.t15 0.20525
R283 O_SENSE.n33 O_SENSE.t14 0.20525
R284 O_SENSE.n35 O_SENSE.t5 0.20525
R285 O_SENSE.n35 O_SENSE.t4 0.20525
R286 O_SENSE.n37 O_SENSE.t21 0.20525
R287 O_SENSE.n37 O_SENSE.t20 0.20525
R288 O_SENSE.n39 O_SENSE.t40 0.20525
R289 O_SENSE.n39 O_SENSE.t39 0.20525
R290 O_SENSE.n41 O_SENSE.t30 0.20525
R291 O_SENSE.n41 O_SENSE.t29 0.20525
R292 O_SENSE.n43 O_SENSE.t13 0.20525
R293 O_SENSE.n43 O_SENSE.t12 0.20525
R294 O_SENSE.n30 O_SENSE.n29 0.189974
R295 O_SENSE.n29 O_SENSE.n27 0.189974
R296 O_SENSE.n27 O_SENSE.n25 0.189974
R297 O_SENSE.n25 O_SENSE.n23 0.189974
R298 O_SENSE.n23 O_SENSE.n21 0.189974
R299 O_SENSE.n21 O_SENSE.n19 0.189974
R300 O_SENSE.n19 O_SENSE.n17 0.189974
R301 O_SENSE.n17 O_SENSE.n15 0.189974
R302 O_SENSE.n15 O_SENSE.n13 0.189974
R303 O_SENSE.n13 O_SENSE.n11 0.189974
R304 O_SENSE.n11 O_SENSE.n9 0.189974
R305 O_SENSE.n9 O_SENSE.n7 0.189974
R306 O_SENSE.n7 O_SENSE.n5 0.189974
R307 O_SENSE.n5 O_SENSE.n3 0.189974
R308 O_SENSE.n3 O_SENSE.n1 0.189974
R309 O_SENSE.n45 O_SENSE.n44 0.189974
R310 O_SENSE.n44 O_SENSE.n42 0.189974
R311 O_SENSE.n42 O_SENSE.n40 0.189974
R312 O_SENSE.n40 O_SENSE.n38 0.189974
R313 O_SENSE.n38 O_SENSE.n36 0.189974
R314 O_SENSE.n36 O_SENSE.n34 0.189974
R315 O_SENSE.n34 O_SENSE.n32 0.189974
R316 O_CAPTURE_CLK O_CAPTURE_CLK.n14 7.98157
R317 O_CAPTURE_CLK.n14 O_CAPTURE_CLK.n6 6.5392
R318 O_CAPTURE_CLK.n8 O_CAPTURE_CLK.t6 5.7796
R319 O_CAPTURE_CLK.n1 O_CAPTURE_CLK.t10 5.73764
R320 O_CAPTURE_CLK.n13 O_CAPTURE_CLK.t5 5.59012
R321 O_CAPTURE_CLK.n6 O_CAPTURE_CLK.t15 5.54817
R322 O_CAPTURE_CLK.n8 O_CAPTURE_CLK.n7 5.38537
R323 O_CAPTURE_CLK.n10 O_CAPTURE_CLK.n9 5.38537
R324 O_CAPTURE_CLK.n12 O_CAPTURE_CLK.n11 5.38537
R325 O_CAPTURE_CLK.n1 O_CAPTURE_CLK.n0 5.32067
R326 O_CAPTURE_CLK.n3 O_CAPTURE_CLK.n2 5.32067
R327 O_CAPTURE_CLK.n5 O_CAPTURE_CLK.n4 5.32067
R328 O_CAPTURE_CLK.n14 O_CAPTURE_CLK.n13 4.61063
R329 O_CAPTURE_CLK.n0 O_CAPTURE_CLK.t2 0.228
R330 O_CAPTURE_CLK.n0 O_CAPTURE_CLK.t11 0.228
R331 O_CAPTURE_CLK.n2 O_CAPTURE_CLK.t8 0.228
R332 O_CAPTURE_CLK.n2 O_CAPTURE_CLK.t3 0.228
R333 O_CAPTURE_CLK.n4 O_CAPTURE_CLK.t14 0.228
R334 O_CAPTURE_CLK.n4 O_CAPTURE_CLK.t9 0.228
R335 O_CAPTURE_CLK.n7 O_CAPTURE_CLK.t12 0.20525
R336 O_CAPTURE_CLK.n7 O_CAPTURE_CLK.t7 0.20525
R337 O_CAPTURE_CLK.n9 O_CAPTURE_CLK.t0 0.20525
R338 O_CAPTURE_CLK.n9 O_CAPTURE_CLK.t13 0.20525
R339 O_CAPTURE_CLK.n11 O_CAPTURE_CLK.t4 0.20525
R340 O_CAPTURE_CLK.n11 O_CAPTURE_CLK.t1 0.20525
R341 O_CAPTURE_CLK.n13 O_CAPTURE_CLK.n12 0.189974
R342 O_CAPTURE_CLK.n12 O_CAPTURE_CLK.n10 0.189974
R343 O_CAPTURE_CLK.n10 O_CAPTURE_CLK.n8 0.189974
R344 O_CAPTURE_CLK.n6 O_CAPTURE_CLK.n5 0.189974
R345 O_CAPTURE_CLK.n5 O_CAPTURE_CLK.n3 0.189974
R346 O_CAPTURE_CLK.n3 O_CAPTURE_CLK.n1 0.189974
R347 O_CAPTURE_CLKB O_CAPTURE_CLKB.n14 6.63157
R348 O_CAPTURE_CLKB.n14 O_CAPTURE_CLKB.n6 6.5392
R349 O_CAPTURE_CLKB.n8 O_CAPTURE_CLKB.t14 5.7796
R350 O_CAPTURE_CLKB.n1 O_CAPTURE_CLKB.t4 5.73764
R351 O_CAPTURE_CLKB.n13 O_CAPTURE_CLKB.t3 5.59012
R352 O_CAPTURE_CLKB.n6 O_CAPTURE_CLKB.t5 5.54817
R353 O_CAPTURE_CLKB.n8 O_CAPTURE_CLKB.n7 5.38537
R354 O_CAPTURE_CLKB.n10 O_CAPTURE_CLKB.n9 5.38537
R355 O_CAPTURE_CLKB.n12 O_CAPTURE_CLKB.n11 5.38537
R356 O_CAPTURE_CLKB.n1 O_CAPTURE_CLKB.n0 5.32067
R357 O_CAPTURE_CLKB.n3 O_CAPTURE_CLKB.n2 5.32067
R358 O_CAPTURE_CLKB.n5 O_CAPTURE_CLKB.n4 5.32067
R359 O_CAPTURE_CLKB.n14 O_CAPTURE_CLKB.n13 4.61063
R360 O_CAPTURE_CLKB.n0 O_CAPTURE_CLKB.t7 0.228
R361 O_CAPTURE_CLKB.n0 O_CAPTURE_CLKB.t6 0.228
R362 O_CAPTURE_CLKB.n2 O_CAPTURE_CLKB.t10 0.228
R363 O_CAPTURE_CLKB.n2 O_CAPTURE_CLKB.t9 0.228
R364 O_CAPTURE_CLKB.n4 O_CAPTURE_CLKB.t2 0.228
R365 O_CAPTURE_CLKB.n4 O_CAPTURE_CLKB.t1 0.228
R366 O_CAPTURE_CLKB.n7 O_CAPTURE_CLKB.t13 0.20525
R367 O_CAPTURE_CLKB.n7 O_CAPTURE_CLKB.t15 0.20525
R368 O_CAPTURE_CLKB.n9 O_CAPTURE_CLKB.t12 0.20525
R369 O_CAPTURE_CLKB.n9 O_CAPTURE_CLKB.t0 0.20525
R370 O_CAPTURE_CLKB.n11 O_CAPTURE_CLKB.t11 0.20525
R371 O_CAPTURE_CLKB.n11 O_CAPTURE_CLKB.t8 0.20525
R372 O_CAPTURE_CLKB.n13 O_CAPTURE_CLKB.n12 0.189974
R373 O_CAPTURE_CLKB.n12 O_CAPTURE_CLKB.n10 0.189974
R374 O_CAPTURE_CLKB.n10 O_CAPTURE_CLKB.n8 0.189974
R375 O_CAPTURE_CLKB.n6 O_CAPTURE_CLKB.n5 0.189974
R376 O_CAPTURE_CLKB.n5 O_CAPTURE_CLKB.n3 0.189974
R377 O_CAPTURE_CLKB.n3 O_CAPTURE_CLKB.n1 0.189974
R378 CLKN_H.n8 CLKN_H.t3 113.632
R379 CLKN_H.n5 CLKN_H.t0 113.632
R380 CLKN_H.n0 CLKN_H.t4 113.632
R381 CLKN_H.n3 CLKN_H.t7 113.632
R382 CLKN_H.n6 CLKN_H.t1 109.174
R383 CLKN_H.n7 CLKN_H.t2 109.174
R384 CLKN_H.n1 CLKN_H.t5 109.174
R385 CLKN_H.n2 CLKN_H.t6 109.174
R386 CLKN_H CLKN_H.n10 15.3874
R387 CLKN_H.n7 CLKN_H.n6 11.6805
R388 CLKN_H.n2 CLKN_H.n1 11.6805
R389 CLKN_H.n10 CLKN_H.n4 10.9291
R390 CLKN_H.n10 CLKN_H.n9 9.0005
R391 CLKN_H.n9 CLKN_H.n5 7.10487
R392 CLKN_H.n9 CLKN_H.n8 7.10487
R393 CLKN_H.n4 CLKN_H.n0 7.10487
R394 CLKN_H.n4 CLKN_H.n3 7.10487
R395 CLKN_H.n6 CLKN_H.n5 4.42851
R396 CLKN_H.n8 CLKN_H.n7 4.42851
R397 CLKN_H.n1 CLKN_H.n0 4.42851
R398 CLKN_H.n3 CLKN_H.n2 4.42851
R399 CLKN_HB.n8 CLKN_HB.t3 113.632
R400 CLKN_HB.n5 CLKN_HB.t0 113.632
R401 CLKN_HB.n3 CLKN_HB.t11 113.632
R402 CLKN_HB.n0 CLKN_HB.t8 113.632
R403 CLKN_HB.n19 CLKN_HB.t7 113.632
R404 CLKN_HB.n16 CLKN_HB.t4 113.632
R405 CLKN_HB.n11 CLKN_HB.t12 113.632
R406 CLKN_HB.n14 CLKN_HB.t15 113.632
R407 CLKN_HB.n6 CLKN_HB.t1 109.174
R408 CLKN_HB.n7 CLKN_HB.t2 109.174
R409 CLKN_HB.n1 CLKN_HB.t9 109.174
R410 CLKN_HB.n2 CLKN_HB.t10 109.174
R411 CLKN_HB.n17 CLKN_HB.t5 109.174
R412 CLKN_HB.n18 CLKN_HB.t6 109.174
R413 CLKN_HB.n12 CLKN_HB.t13 109.174
R414 CLKN_HB.n13 CLKN_HB.t14 109.174
R415 CLKN_HB.n7 CLKN_HB.n6 11.6805
R416 CLKN_HB.n2 CLKN_HB.n1 11.6805
R417 CLKN_HB.n18 CLKN_HB.n17 11.6805
R418 CLKN_HB.n13 CLKN_HB.n12 11.6805
R419 CLKN_HB.n10 CLKN_HB.n4 10.9291
R420 CLKN_HB.n21 CLKN_HB.n15 10.9291
R421 CLKN_HB CLKN_HB.n22 9.03615
R422 CLKN_HB.n10 CLKN_HB.n9 9.0005
R423 CLKN_HB.n21 CLKN_HB.n20 9.0005
R424 CLKN_HB.n22 CLKN_HB.n10 8.70954
R425 CLKN_HB.n9 CLKN_HB.n5 7.10487
R426 CLKN_HB.n9 CLKN_HB.n8 7.10487
R427 CLKN_HB.n4 CLKN_HB.n0 7.10487
R428 CLKN_HB.n4 CLKN_HB.n3 7.10487
R429 CLKN_HB.n20 CLKN_HB.n16 7.10487
R430 CLKN_HB.n20 CLKN_HB.n19 7.10487
R431 CLKN_HB.n15 CLKN_HB.n11 7.10487
R432 CLKN_HB.n15 CLKN_HB.n14 7.10487
R433 CLKN_HB.n22 CLKN_HB.n21 4.59693
R434 CLKN_HB.n6 CLKN_HB.n5 4.42851
R435 CLKN_HB.n8 CLKN_HB.n7 4.42851
R436 CLKN_HB.n1 CLKN_HB.n0 4.42851
R437 CLKN_HB.n3 CLKN_HB.n2 4.42851
R438 CLKN_HB.n17 CLKN_HB.n16 4.42851
R439 CLKN_HB.n19 CLKN_HB.n18 4.42851
R440 CLKN_HB.n12 CLKN_HB.n11 4.42851
R441 CLKN_HB.n14 CLKN_HB.n13 4.42851
R442 VDD.t232 VDD.t144 450.829
R443 VDD.t136 VDD.t238 450.829
R444 VDD.t64 VDD.t132 450.829
R445 VDD.t194 VDD.t46 450.829
R446 VDD.t250 VDD.t174 450.829
R447 VDD.t82 VDD.t274 450.829
R448 VDD.t206 VDD.t160 450.829
R449 VDD.t152 VDD.t212 450.829
R450 VDD.t214 VDD.t148 450.829
R451 VDD.t18 VDD.t216 450.829
R452 VDD.t190 VDD.t80 450.829
R453 VDD.t186 VDD.t182 450.829
R454 VDD.t142 VDD.n79 417.582
R455 VDD.t158 VDD.n1 417.582
R456 VDD.n80 VDD.t266 245.21
R457 VDD.n2 VDD.t264 245.21
R458 VDD.t140 VDD.t142 44.1994
R459 VDD.t138 VDD.t140 44.1994
R460 VDD.t144 VDD.t138 44.1994
R461 VDD.t234 VDD.t232 44.1994
R462 VDD.t236 VDD.t234 44.1994
R463 VDD.t238 VDD.t236 44.1994
R464 VDD.t134 VDD.t136 44.1994
R465 VDD.t146 VDD.t134 44.1994
R466 VDD.t132 VDD.t146 44.1994
R467 VDD.t44 VDD.t64 44.1994
R468 VDD.t42 VDD.t44 44.1994
R469 VDD.t198 VDD.t42 44.1994
R470 VDD.t196 VDD.t198 44.1994
R471 VDD.t68 VDD.t196 44.1994
R472 VDD.t66 VDD.t68 44.1994
R473 VDD.t46 VDD.t66 44.1994
R474 VDD.t192 VDD.t194 44.1994
R475 VDD.t62 VDD.t192 44.1994
R476 VDD.t60 VDD.t62 44.1994
R477 VDD.t40 VDD.t60 44.1994
R478 VDD.t38 VDD.t40 44.1994
R479 VDD.t176 VDD.t38 44.1994
R480 VDD.t174 VDD.t176 44.1994
R481 VDD.t248 VDD.t250 44.1994
R482 VDD.t286 VDD.t248 44.1994
R483 VDD.t284 VDD.t286 44.1994
R484 VDD.t242 VDD.t284 44.1994
R485 VDD.t240 VDD.t242 44.1994
R486 VDD.t246 VDD.t240 44.1994
R487 VDD.t244 VDD.t246 44.1994
R488 VDD.t254 VDD.t244 44.1994
R489 VDD.t252 VDD.t254 44.1994
R490 VDD.t276 VDD.t252 44.1994
R491 VDD.t274 VDD.t276 44.1994
R492 VDD.t172 VDD.t82 44.1994
R493 VDD.t122 VDD.t172 44.1994
R494 VDD.t262 VDD.t122 44.1994
R495 VDD.t260 VDD.t262 44.1994
R496 VDD.t108 VDD.t260 44.1994
R497 VDD.t106 VDD.t108 44.1994
R498 VDD.t26 VDD.t106 44.1994
R499 VDD.t24 VDD.t26 44.1994
R500 VDD.t86 VDD.t24 44.1994
R501 VDD.t84 VDD.t86 44.1994
R502 VDD.t50 VDD.t84 44.1994
R503 VDD.t48 VDD.t50 44.1994
R504 VDD.t4 VDD.t48 44.1994
R505 VDD.t2 VDD.t4 44.1994
R506 VDD.t30 VDD.t2 44.1994
R507 VDD.t28 VDD.t30 44.1994
R508 VDD.t90 VDD.t28 44.1994
R509 VDD.t88 VDD.t90 44.1994
R510 VDD.t104 VDD.t88 44.1994
R511 VDD.t102 VDD.t104 44.1994
R512 VDD.t54 VDD.t102 44.1994
R513 VDD.t52 VDD.t54 44.1994
R514 VDD.t8 VDD.t52 44.1994
R515 VDD.t6 VDD.t8 44.1994
R516 VDD.t34 VDD.t6 44.1994
R517 VDD.t32 VDD.t34 44.1994
R518 VDD.t94 VDD.t32 44.1994
R519 VDD.t92 VDD.t94 44.1994
R520 VDD.t120 VDD.t92 44.1994
R521 VDD.t118 VDD.t120 44.1994
R522 VDD.t266 VDD.t118 44.1994
R523 VDD.t154 VDD.t158 44.1994
R524 VDD.t156 VDD.t154 44.1994
R525 VDD.t160 VDD.t156 44.1994
R526 VDD.t208 VDD.t206 44.1994
R527 VDD.t210 VDD.t208 44.1994
R528 VDD.t212 VDD.t210 44.1994
R529 VDD.t150 VDD.t152 44.1994
R530 VDD.t162 VDD.t150 44.1994
R531 VDD.t148 VDD.t162 44.1994
R532 VDD.t96 VDD.t214 44.1994
R533 VDD.t10 VDD.t96 44.1994
R534 VDD.t36 VDD.t10 44.1994
R535 VDD.t12 VDD.t36 44.1994
R536 VDD.t72 VDD.t12 44.1994
R537 VDD.t74 VDD.t72 44.1994
R538 VDD.t216 VDD.t74 44.1994
R539 VDD.t78 VDD.t18 44.1994
R540 VDD.t76 VDD.t78 44.1994
R541 VDD.t258 VDD.t76 44.1994
R542 VDD.t256 VDD.t258 44.1994
R543 VDD.t22 VDD.t256 44.1994
R544 VDD.t20 VDD.t22 44.1994
R545 VDD.t80 VDD.t20 44.1994
R546 VDD.t188 VDD.t190 44.1994
R547 VDD.t100 VDD.t188 44.1994
R548 VDD.t98 VDD.t100 44.1994
R549 VDD.t112 VDD.t98 44.1994
R550 VDD.t110 VDD.t112 44.1994
R551 VDD.t170 VDD.t110 44.1994
R552 VDD.t168 VDD.t170 44.1994
R553 VDD.t116 VDD.t168 44.1994
R554 VDD.t114 VDD.t116 44.1994
R555 VDD.t184 VDD.t114 44.1994
R556 VDD.t182 VDD.t184 44.1994
R557 VDD.t268 VDD.t186 44.1994
R558 VDD.t200 VDD.t268 44.1994
R559 VDD.t0 VDD.t200 44.1994
R560 VDD.t218 VDD.t0 44.1994
R561 VDD.t70 VDD.t218 44.1994
R562 VDD.t278 VDD.t70 44.1994
R563 VDD.t58 VDD.t278 44.1994
R564 VDD.t56 VDD.t58 44.1994
R565 VDD.t16 VDD.t56 44.1994
R566 VDD.t14 VDD.t16 44.1994
R567 VDD.t126 VDD.t14 44.1994
R568 VDD.t124 VDD.t126 44.1994
R569 VDD.t166 VDD.t124 44.1994
R570 VDD.t164 VDD.t166 44.1994
R571 VDD.t226 VDD.t164 44.1994
R572 VDD.t224 VDD.t226 44.1994
R573 VDD.t272 VDD.t224 44.1994
R574 VDD.t270 VDD.t272 44.1994
R575 VDD.t204 VDD.t270 44.1994
R576 VDD.t202 VDD.t204 44.1994
R577 VDD.t222 VDD.t202 44.1994
R578 VDD.t220 VDD.t222 44.1994
R579 VDD.t282 VDD.t220 44.1994
R580 VDD.t280 VDD.t282 44.1994
R581 VDD.t130 VDD.t280 44.1994
R582 VDD.t128 VDD.t130 44.1994
R583 VDD.t180 VDD.t128 44.1994
R584 VDD.t178 VDD.t180 44.1994
R585 VDD.t230 VDD.t178 44.1994
R586 VDD.t228 VDD.t230 44.1994
R587 VDD.t264 VDD.t228 44.1994
R588 VDD.n112 VDD.n111 11.1661
R589 VDD.n124 VDD.n123 11.1661
R590 VDD.n132 VDD.n131 11.1661
R591 VDD.n140 VDD.n139 11.1661
R592 VDD.n144 VDD.n143 11.1661
R593 VDD.n148 VDD.n147 11.1661
R594 VDD.n152 VDD.n151 11.1661
R595 VDD.n34 VDD.n33 11.1661
R596 VDD.n46 VDD.n45 11.1661
R597 VDD.n54 VDD.n53 11.1661
R598 VDD.n62 VDD.n61 11.1661
R599 VDD.n66 VDD.n65 11.1661
R600 VDD.n70 VDD.n69 11.1661
R601 VDD.n74 VDD.n73 11.1661
R602 VDD.n83 VDD.n81 5.51014
R603 VDD.n115 VDD.n113 5.51014
R604 VDD.n127 VDD.n125 5.51014
R605 VDD.n135 VDD.n133 5.51014
R606 VDD.n143 VDD.n141 5.51014
R607 VDD.n147 VDD.n145 5.51014
R608 VDD.n151 VDD.n149 5.51014
R609 VDD.n5 VDD.n3 5.51014
R610 VDD.n37 VDD.n35 5.51014
R611 VDD.n49 VDD.n47 5.51014
R612 VDD.n57 VDD.n55 5.51014
R613 VDD.n65 VDD.n63 5.51014
R614 VDD.n69 VDD.n67 5.51014
R615 VDD.n73 VDD.n71 5.51014
R616 VDD.n111 VDD.n110 5.32067
R617 VDD.n109 VDD.n108 5.32067
R618 VDD.n107 VDD.n106 5.32067
R619 VDD.n105 VDD.n104 5.32067
R620 VDD.n103 VDD.n102 5.32067
R621 VDD.n101 VDD.n100 5.32067
R622 VDD.n99 VDD.n98 5.32067
R623 VDD.n97 VDD.n96 5.32067
R624 VDD.n95 VDD.n94 5.32067
R625 VDD.n93 VDD.n92 5.32067
R626 VDD.n91 VDD.n90 5.32067
R627 VDD.n89 VDD.n88 5.32067
R628 VDD.n87 VDD.n86 5.32067
R629 VDD.n85 VDD.n84 5.32067
R630 VDD.n83 VDD.n82 5.32067
R631 VDD.n123 VDD.n122 5.32067
R632 VDD.n121 VDD.n120 5.32067
R633 VDD.n119 VDD.n118 5.32067
R634 VDD.n117 VDD.n116 5.32067
R635 VDD.n115 VDD.n114 5.32067
R636 VDD.n131 VDD.n130 5.32067
R637 VDD.n129 VDD.n128 5.32067
R638 VDD.n127 VDD.n126 5.32067
R639 VDD.n139 VDD.n138 5.32067
R640 VDD.n137 VDD.n136 5.32067
R641 VDD.n135 VDD.n134 5.32067
R642 VDD.n143 VDD.n142 5.32067
R643 VDD.n147 VDD.n146 5.32067
R644 VDD.n151 VDD.n150 5.32067
R645 VDD.n33 VDD.n32 5.32067
R646 VDD.n31 VDD.n30 5.32067
R647 VDD.n29 VDD.n28 5.32067
R648 VDD.n27 VDD.n26 5.32067
R649 VDD.n25 VDD.n24 5.32067
R650 VDD.n23 VDD.n22 5.32067
R651 VDD.n21 VDD.n20 5.32067
R652 VDD.n19 VDD.n18 5.32067
R653 VDD.n17 VDD.n16 5.32067
R654 VDD.n15 VDD.n14 5.32067
R655 VDD.n13 VDD.n12 5.32067
R656 VDD.n11 VDD.n10 5.32067
R657 VDD.n9 VDD.n8 5.32067
R658 VDD.n7 VDD.n6 5.32067
R659 VDD.n5 VDD.n4 5.32067
R660 VDD.n45 VDD.n44 5.32067
R661 VDD.n43 VDD.n42 5.32067
R662 VDD.n41 VDD.n40 5.32067
R663 VDD.n39 VDD.n38 5.32067
R664 VDD.n37 VDD.n36 5.32067
R665 VDD.n53 VDD.n52 5.32067
R666 VDD.n51 VDD.n50 5.32067
R667 VDD.n49 VDD.n48 5.32067
R668 VDD.n61 VDD.n60 5.32067
R669 VDD.n59 VDD.n58 5.32067
R670 VDD.n57 VDD.n56 5.32067
R671 VDD.n65 VDD.n64 5.32067
R672 VDD.n69 VDD.n68 5.32067
R673 VDD.n73 VDD.n72 5.32067
R674 VDD.n78 VDD.n0 4.5005
R675 VDD.n156 VDD.n0 4.5005
R676 VDD.n78 VDD.n77 3.31026
R677 VDD.n156 VDD.n155 2.76928
R678 VDD.n158 VDD.n157 2.26839
R679 VDD.n155 VDD.n154 2.2545
R680 VDD.n77 VDD.n76 2.2545
R681 VDD.n154 VDD.n153 2.2505
R682 VDD.n76 VDD.n75 2.2505
R683 VDD.n154 VDD.n80 1.86985
R684 VDD.n76 VDD.n2 1.86985
R685 VDD VDD.n158 1.13544
R686 VDD.n124 VDD.n112 0.7421
R687 VDD.n46 VDD.n34 0.7421
R688 VDD.n132 VDD.n124 0.3821
R689 VDD.n54 VDD.n46 0.3821
R690 VDD.n144 VDD.n140 0.3101
R691 VDD.n140 VDD.n132 0.3101
R692 VDD.n66 VDD.n62 0.3101
R693 VDD.n62 VDD.n54 0.3101
R694 VDD.n152 VDD.n148 0.2381
R695 VDD.n148 VDD.n144 0.2381
R696 VDD.n74 VDD.n70 0.2381
R697 VDD.n70 VDD.n66 0.2381
R698 VDD.n153 VDD.n152 0.236975
R699 VDD.n75 VDD.n74 0.236975
R700 VDD.n110 VDD.t119 0.228
R701 VDD.n110 VDD.t267 0.228
R702 VDD.n108 VDD.t93 0.228
R703 VDD.n108 VDD.t121 0.228
R704 VDD.n106 VDD.t33 0.228
R705 VDD.n106 VDD.t95 0.228
R706 VDD.n104 VDD.t7 0.228
R707 VDD.n104 VDD.t35 0.228
R708 VDD.n102 VDD.t53 0.228
R709 VDD.n102 VDD.t9 0.228
R710 VDD.n100 VDD.t103 0.228
R711 VDD.n100 VDD.t55 0.228
R712 VDD.n98 VDD.t89 0.228
R713 VDD.n98 VDD.t105 0.228
R714 VDD.n96 VDD.t29 0.228
R715 VDD.n96 VDD.t91 0.228
R716 VDD.n94 VDD.t3 0.228
R717 VDD.n94 VDD.t31 0.228
R718 VDD.n92 VDD.t49 0.228
R719 VDD.n92 VDD.t5 0.228
R720 VDD.n90 VDD.t85 0.228
R721 VDD.n90 VDD.t51 0.228
R722 VDD.n88 VDD.t25 0.228
R723 VDD.n88 VDD.t87 0.228
R724 VDD.n86 VDD.t107 0.228
R725 VDD.n86 VDD.t27 0.228
R726 VDD.n84 VDD.t261 0.228
R727 VDD.n84 VDD.t109 0.228
R728 VDD.n82 VDD.t123 0.228
R729 VDD.n82 VDD.t263 0.228
R730 VDD.n81 VDD.t83 0.228
R731 VDD.n81 VDD.t173 0.228
R732 VDD.n122 VDD.t277 0.228
R733 VDD.n122 VDD.t275 0.228
R734 VDD.n120 VDD.t255 0.228
R735 VDD.n120 VDD.t253 0.228
R736 VDD.n118 VDD.t247 0.228
R737 VDD.n118 VDD.t245 0.228
R738 VDD.n116 VDD.t243 0.228
R739 VDD.n116 VDD.t241 0.228
R740 VDD.n114 VDD.t287 0.228
R741 VDD.n114 VDD.t285 0.228
R742 VDD.n113 VDD.t251 0.228
R743 VDD.n113 VDD.t249 0.228
R744 VDD.n130 VDD.t177 0.228
R745 VDD.n130 VDD.t175 0.228
R746 VDD.n128 VDD.t41 0.228
R747 VDD.n128 VDD.t39 0.228
R748 VDD.n126 VDD.t63 0.228
R749 VDD.n126 VDD.t61 0.228
R750 VDD.n125 VDD.t195 0.228
R751 VDD.n125 VDD.t193 0.228
R752 VDD.n138 VDD.t67 0.228
R753 VDD.n138 VDD.t47 0.228
R754 VDD.n136 VDD.t197 0.228
R755 VDD.n136 VDD.t69 0.228
R756 VDD.n134 VDD.t43 0.228
R757 VDD.n134 VDD.t199 0.228
R758 VDD.n133 VDD.t65 0.228
R759 VDD.n133 VDD.t45 0.228
R760 VDD.n142 VDD.t147 0.228
R761 VDD.n142 VDD.t133 0.228
R762 VDD.n141 VDD.t137 0.228
R763 VDD.n141 VDD.t135 0.228
R764 VDD.n146 VDD.t237 0.228
R765 VDD.n146 VDD.t239 0.228
R766 VDD.n145 VDD.t233 0.228
R767 VDD.n145 VDD.t235 0.228
R768 VDD.n150 VDD.t139 0.228
R769 VDD.n150 VDD.t145 0.228
R770 VDD.n149 VDD.t143 0.228
R771 VDD.n149 VDD.t141 0.228
R772 VDD.n32 VDD.t229 0.228
R773 VDD.n32 VDD.t265 0.228
R774 VDD.n30 VDD.t179 0.228
R775 VDD.n30 VDD.t231 0.228
R776 VDD.n28 VDD.t129 0.228
R777 VDD.n28 VDD.t181 0.228
R778 VDD.n26 VDD.t281 0.228
R779 VDD.n26 VDD.t131 0.228
R780 VDD.n24 VDD.t221 0.228
R781 VDD.n24 VDD.t283 0.228
R782 VDD.n22 VDD.t203 0.228
R783 VDD.n22 VDD.t223 0.228
R784 VDD.n20 VDD.t271 0.228
R785 VDD.n20 VDD.t205 0.228
R786 VDD.n18 VDD.t225 0.228
R787 VDD.n18 VDD.t273 0.228
R788 VDD.n16 VDD.t165 0.228
R789 VDD.n16 VDD.t227 0.228
R790 VDD.n14 VDD.t125 0.228
R791 VDD.n14 VDD.t167 0.228
R792 VDD.n12 VDD.t15 0.228
R793 VDD.n12 VDD.t127 0.228
R794 VDD.n10 VDD.t57 0.228
R795 VDD.n10 VDD.t17 0.228
R796 VDD.n8 VDD.t279 0.228
R797 VDD.n8 VDD.t59 0.228
R798 VDD.n6 VDD.t219 0.228
R799 VDD.n6 VDD.t71 0.228
R800 VDD.n4 VDD.t201 0.228
R801 VDD.n4 VDD.t1 0.228
R802 VDD.n3 VDD.t187 0.228
R803 VDD.n3 VDD.t269 0.228
R804 VDD.n44 VDD.t185 0.228
R805 VDD.n44 VDD.t183 0.228
R806 VDD.n42 VDD.t117 0.228
R807 VDD.n42 VDD.t115 0.228
R808 VDD.n40 VDD.t171 0.228
R809 VDD.n40 VDD.t169 0.228
R810 VDD.n38 VDD.t113 0.228
R811 VDD.n38 VDD.t111 0.228
R812 VDD.n36 VDD.t101 0.228
R813 VDD.n36 VDD.t99 0.228
R814 VDD.n35 VDD.t191 0.228
R815 VDD.n35 VDD.t189 0.228
R816 VDD.n52 VDD.t21 0.228
R817 VDD.n52 VDD.t81 0.228
R818 VDD.n50 VDD.t257 0.228
R819 VDD.n50 VDD.t23 0.228
R820 VDD.n48 VDD.t77 0.228
R821 VDD.n48 VDD.t259 0.228
R822 VDD.n47 VDD.t19 0.228
R823 VDD.n47 VDD.t79 0.228
R824 VDD.n60 VDD.t75 0.228
R825 VDD.n60 VDD.t217 0.228
R826 VDD.n58 VDD.t13 0.228
R827 VDD.n58 VDD.t73 0.228
R828 VDD.n56 VDD.t11 0.228
R829 VDD.n56 VDD.t37 0.228
R830 VDD.n55 VDD.t215 0.228
R831 VDD.n55 VDD.t97 0.228
R832 VDD.n64 VDD.t163 0.228
R833 VDD.n64 VDD.t149 0.228
R834 VDD.n63 VDD.t153 0.228
R835 VDD.n63 VDD.t151 0.228
R836 VDD.n68 VDD.t211 0.228
R837 VDD.n68 VDD.t213 0.228
R838 VDD.n67 VDD.t207 0.228
R839 VDD.n67 VDD.t209 0.228
R840 VDD.n72 VDD.t157 0.228
R841 VDD.n72 VDD.t161 0.228
R842 VDD.n71 VDD.t159 0.228
R843 VDD.n71 VDD.t155 0.228
R844 VDD.n85 VDD.n83 0.189974
R845 VDD.n87 VDD.n85 0.189974
R846 VDD.n89 VDD.n87 0.189974
R847 VDD.n91 VDD.n89 0.189974
R848 VDD.n93 VDD.n91 0.189974
R849 VDD.n95 VDD.n93 0.189974
R850 VDD.n97 VDD.n95 0.189974
R851 VDD.n99 VDD.n97 0.189974
R852 VDD.n101 VDD.n99 0.189974
R853 VDD.n103 VDD.n101 0.189974
R854 VDD.n105 VDD.n103 0.189974
R855 VDD.n107 VDD.n105 0.189974
R856 VDD.n109 VDD.n107 0.189974
R857 VDD.n111 VDD.n109 0.189974
R858 VDD.n117 VDD.n115 0.189974
R859 VDD.n119 VDD.n117 0.189974
R860 VDD.n121 VDD.n119 0.189974
R861 VDD.n123 VDD.n121 0.189974
R862 VDD.n129 VDD.n127 0.189974
R863 VDD.n131 VDD.n129 0.189974
R864 VDD.n137 VDD.n135 0.189974
R865 VDD.n139 VDD.n137 0.189974
R866 VDD.n7 VDD.n5 0.189974
R867 VDD.n9 VDD.n7 0.189974
R868 VDD.n11 VDD.n9 0.189974
R869 VDD.n13 VDD.n11 0.189974
R870 VDD.n15 VDD.n13 0.189974
R871 VDD.n17 VDD.n15 0.189974
R872 VDD.n19 VDD.n17 0.189974
R873 VDD.n21 VDD.n19 0.189974
R874 VDD.n23 VDD.n21 0.189974
R875 VDD.n25 VDD.n23 0.189974
R876 VDD.n27 VDD.n25 0.189974
R877 VDD.n29 VDD.n27 0.189974
R878 VDD.n31 VDD.n29 0.189974
R879 VDD.n33 VDD.n31 0.189974
R880 VDD.n39 VDD.n37 0.189974
R881 VDD.n41 VDD.n39 0.189974
R882 VDD.n43 VDD.n41 0.189974
R883 VDD.n45 VDD.n43 0.189974
R884 VDD.n51 VDD.n49 0.189974
R885 VDD.n53 VDD.n51 0.189974
R886 VDD.n59 VDD.n57 0.189974
R887 VDD.n61 VDD.n59 0.189974
R888 VDD.n112 VDD.n80 0.0571608
R889 VDD.n34 VDD.n2 0.0571608
R890 VDD.n158 VDD.n0 0.020105
R891 VDD.n155 VDD.n79 0.00725
R892 VDD.n153 VDD.n79 0.00725
R893 VDD.n77 VDD.n1 0.00725
R894 VDD.n75 VDD.n1 0.00725
R895 VDD.n157 VDD.n156 0.0054955
R896 VDD.n157 VDD.n78 0.0054955
R897 VSS.n70 VSS.n69 5121.21
R898 VSS.n133 VSS.n70 5121.21
R899 VSS.n67 VSS.n66 4481.39
R900 VSS.n134 VSS.n133 4318.81
R901 VSS.n68 VSS.n67 3545.45
R902 VSS.n69 VSS.n68 3545.45
R903 VSS.t194 VSS.t196 2643.58
R904 VSS.t198 VSS.t212 2643.58
R905 VSS.n6 VSS.t156 1905.23
R906 VSS.n128 VSS.t82 1905.23
R907 VSS.t134 VSS.t116 1481.56
R908 VSS.t108 VSS.t132 1481.56
R909 VSS.t174 VSS.t122 1481.56
R910 VSS.t62 VSS.t154 1481.56
R911 VSS.t168 VSS.t64 1481.56
R912 VSS.t152 VSS.t100 1481.56
R913 VSS.t92 VSS.t150 1481.56
R914 VSS.t32 VSS.t106 1481.56
R915 VSS.t48 VSS.t188 1481.56
R916 VSS.t140 VSS.t50 1481.56
R917 VSS.t110 VSS.n4 1285.47
R918 VSS.n132 VSS.t94 1285.47
R919 VSS.n68 VSS.n3 933.923
R920 VSS.n69 VSS.n2 933.923
R921 VSS.n67 VSS.n4 907.822
R922 VSS.n133 VSS.n132 907.822
R923 VSS.n135 VSS.n70 351.702
R924 VSS.t112 VSS.t110 145.251
R925 VSS.t114 VSS.t112 145.251
R926 VSS.t116 VSS.t114 145.251
R927 VSS.t136 VSS.t134 145.251
R928 VSS.t130 VSS.t136 145.251
R929 VSS.t132 VSS.t130 145.251
R930 VSS.t118 VSS.t108 145.251
R931 VSS.t120 VSS.t118 145.251
R932 VSS.t122 VSS.t120 145.251
R933 VSS.t42 VSS.t174 145.251
R934 VSS.t204 VSS.t42 145.251
R935 VSS.t206 VSS.t204 145.251
R936 VSS.t44 VSS.t206 145.251
R937 VSS.t222 VSS.t44 145.251
R938 VSS.t54 VSS.t222 145.251
R939 VSS.t154 VSS.t54 145.251
R940 VSS.t36 VSS.t62 145.251
R941 VSS.t34 VSS.t36 145.251
R942 VSS.t6 VSS.t34 145.251
R943 VSS.t4 VSS.t6 145.251
R944 VSS.t22 VSS.t4 145.251
R945 VSS.t20 VSS.t22 145.251
R946 VSS.t64 VSS.t20 145.251
R947 VSS.t166 VSS.t168 145.251
R948 VSS.t164 VSS.t166 145.251
R949 VSS.t162 VSS.t164 145.251
R950 VSS.t160 VSS.t162 145.251
R951 VSS.t158 VSS.t160 145.251
R952 VSS.t76 VSS.t158 145.251
R953 VSS.t74 VSS.t76 145.251
R954 VSS.t184 VSS.t74 145.251
R955 VSS.t182 VSS.t184 145.251
R956 VSS.t190 VSS.t182 145.251
R957 VSS.t196 VSS.t190 145.251
R958 VSS.t2 VSS.t194 145.251
R959 VSS.t0 VSS.t2 145.251
R960 VSS.t60 VSS.t0 145.251
R961 VSS.t58 VSS.t60 145.251
R962 VSS.t210 VSS.t58 145.251
R963 VSS.t208 VSS.t210 145.251
R964 VSS.t86 VSS.t208 145.251
R965 VSS.t84 VSS.t86 145.251
R966 VSS.t202 VSS.t84 145.251
R967 VSS.t200 VSS.t202 145.251
R968 VSS.t90 VSS.t200 145.251
R969 VSS.t88 VSS.t90 145.251
R970 VSS.t178 VSS.t88 145.251
R971 VSS.t176 VSS.t178 145.251
R972 VSS.t156 VSS.t176 145.251
R973 VSS.t96 VSS.t94 145.251
R974 VSS.t98 VSS.t96 145.251
R975 VSS.t100 VSS.t98 145.251
R976 VSS.t148 VSS.t152 145.251
R977 VSS.t146 VSS.t148 145.251
R978 VSS.t150 VSS.t146 145.251
R979 VSS.t102 VSS.t92 145.251
R980 VSS.t104 VSS.t102 145.251
R981 VSS.t106 VSS.t104 145.251
R982 VSS.t128 VSS.t32 145.251
R983 VSS.t56 VSS.t128 145.251
R984 VSS.t180 VSS.t56 145.251
R985 VSS.t18 VSS.t180 145.251
R986 VSS.t186 VSS.t18 145.251
R987 VSS.t192 VSS.t186 145.251
R988 VSS.t188 VSS.t192 145.251
R989 VSS.t46 VSS.t48 145.251
R990 VSS.t16 VSS.t46 145.251
R991 VSS.t14 VSS.t16 145.251
R992 VSS.t126 VSS.t14 145.251
R993 VSS.t124 VSS.t126 145.251
R994 VSS.t52 VSS.t124 145.251
R995 VSS.t50 VSS.t52 145.251
R996 VSS.t138 VSS.t140 145.251
R997 VSS.t220 VSS.t138 145.251
R998 VSS.t218 VSS.t220 145.251
R999 VSS.t144 VSS.t218 145.251
R1000 VSS.t142 VSS.t144 145.251
R1001 VSS.t216 VSS.t142 145.251
R1002 VSS.t214 VSS.t216 145.251
R1003 VSS.t172 VSS.t214 145.251
R1004 VSS.t170 VSS.t172 145.251
R1005 VSS.t12 VSS.t170 145.251
R1006 VSS.t212 VSS.t12 145.251
R1007 VSS.t26 VSS.t198 145.251
R1008 VSS.t24 VSS.t26 145.251
R1009 VSS.t68 VSS.t24 145.251
R1010 VSS.t66 VSS.t68 145.251
R1011 VSS.t80 VSS.t66 145.251
R1012 VSS.t78 VSS.t80 145.251
R1013 VSS.t40 VSS.t78 145.251
R1014 VSS.t38 VSS.t40 145.251
R1015 VSS.t10 VSS.t38 145.251
R1016 VSS.t8 VSS.t10 145.251
R1017 VSS.t30 VSS.t8 145.251
R1018 VSS.t28 VSS.t30 145.251
R1019 VSS.t72 VSS.t28 145.251
R1020 VSS.t70 VSS.t72 145.251
R1021 VSS.t82 VSS.t70 145.251
R1022 VSS.n5 VSS.n4 24.2219
R1023 VSS.n132 VSS.n131 24.2219
R1024 VSS.n22 VSS.n21 9.9768
R1025 VSS.n34 VSS.n33 9.9768
R1026 VSS.n42 VSS.n41 9.9768
R1027 VSS.n50 VSS.n49 9.9768
R1028 VSS.n54 VSS.n53 9.9768
R1029 VSS.n58 VSS.n57 9.9768
R1030 VSS.n62 VSS.n61 9.9768
R1031 VSS.n127 VSS.n126 9.9768
R1032 VSS.n111 VSS.n110 9.9768
R1033 VSS.n99 VSS.n98 9.9768
R1034 VSS.n91 VSS.n90 9.9768
R1035 VSS.n83 VSS.n82 9.9768
R1036 VSS.n79 VSS.n78 9.9768
R1037 VSS.n75 VSS.n74 9.9768
R1038 VSS.n9 VSS.n7 5.57485
R1039 VSS.n25 VSS.n23 5.57485
R1040 VSS.n37 VSS.n35 5.57485
R1041 VSS.n45 VSS.n43 5.57485
R1042 VSS.n53 VSS.n51 5.57485
R1043 VSS.n57 VSS.n55 5.57485
R1044 VSS.n61 VSS.n59 5.57485
R1045 VSS.n114 VSS.n112 5.57485
R1046 VSS.n102 VSS.n100 5.57485
R1047 VSS.n94 VSS.n92 5.57485
R1048 VSS.n86 VSS.n84 5.57485
R1049 VSS.n82 VSS.n80 5.57485
R1050 VSS.n78 VSS.n76 5.57485
R1051 VSS.n74 VSS.n72 5.57485
R1052 VSS.n21 VSS.n20 5.38537
R1053 VSS.n19 VSS.n18 5.38537
R1054 VSS.n17 VSS.n16 5.38537
R1055 VSS.n15 VSS.n14 5.38537
R1056 VSS.n13 VSS.n12 5.38537
R1057 VSS.n11 VSS.n10 5.38537
R1058 VSS.n9 VSS.n8 5.38537
R1059 VSS.n33 VSS.n32 5.38537
R1060 VSS.n31 VSS.n30 5.38537
R1061 VSS.n29 VSS.n28 5.38537
R1062 VSS.n27 VSS.n26 5.38537
R1063 VSS.n25 VSS.n24 5.38537
R1064 VSS.n41 VSS.n40 5.38537
R1065 VSS.n39 VSS.n38 5.38537
R1066 VSS.n37 VSS.n36 5.38537
R1067 VSS.n49 VSS.n48 5.38537
R1068 VSS.n47 VSS.n46 5.38537
R1069 VSS.n45 VSS.n44 5.38537
R1070 VSS.n53 VSS.n52 5.38537
R1071 VSS.n57 VSS.n56 5.38537
R1072 VSS.n61 VSS.n60 5.38537
R1073 VSS.n126 VSS.n125 5.38537
R1074 VSS.n124 VSS.n123 5.38537
R1075 VSS.n122 VSS.n121 5.38537
R1076 VSS.n120 VSS.n119 5.38537
R1077 VSS.n118 VSS.n117 5.38537
R1078 VSS.n116 VSS.n115 5.38537
R1079 VSS.n114 VSS.n113 5.38537
R1080 VSS.n110 VSS.n109 5.38537
R1081 VSS.n108 VSS.n107 5.38537
R1082 VSS.n106 VSS.n105 5.38537
R1083 VSS.n104 VSS.n103 5.38537
R1084 VSS.n102 VSS.n101 5.38537
R1085 VSS.n98 VSS.n97 5.38537
R1086 VSS.n96 VSS.n95 5.38537
R1087 VSS.n94 VSS.n93 5.38537
R1088 VSS.n90 VSS.n89 5.38537
R1089 VSS.n88 VSS.n87 5.38537
R1090 VSS.n86 VSS.n85 5.38537
R1091 VSS.n82 VSS.n81 5.38537
R1092 VSS.n78 VSS.n77 5.38537
R1093 VSS.n74 VSS.n73 5.38537
R1094 VSS.n1 VSS.n0 4.5005
R1095 VSS.n136 VSS.n0 4.5005
R1096 VSS.n138 VSS.n137 2.26839
R1097 VSS.n65 VSS.n64 2.2545
R1098 VSS.n129 VSS.n71 2.2545
R1099 VSS.n64 VSS.n63 2.2505
R1100 VSS.n130 VSS.n129 2.2505
R1101 VSS.n66 VSS.n65 1.90124
R1102 VSS.n134 VSS.n71 1.90124
R1103 VSS.n64 VSS.n6 1.86985
R1104 VSS.n129 VSS.n128 1.86985
R1105 VSS VSS.n138 1.13544
R1106 VSS.n34 VSS.n22 0.5981
R1107 VSS.n127 VSS.n111 0.5981
R1108 VSS.n66 VSS.n3 0.543479
R1109 VSS.n3 VSS.n2 0.543479
R1110 VSS.n135 VSS.n134 0.543479
R1111 VSS.n2 VSS.n1 0.507615
R1112 VSS.n136 VSS.n135 0.507363
R1113 VSS.n42 VSS.n34 0.3821
R1114 VSS.n111 VSS.n99 0.3821
R1115 VSS.n54 VSS.n50 0.3101
R1116 VSS.n50 VSS.n42 0.3101
R1117 VSS.n91 VSS.n83 0.3101
R1118 VSS.n99 VSS.n91 0.3101
R1119 VSS.n62 VSS.n58 0.2381
R1120 VSS.n58 VSS.n54 0.2381
R1121 VSS.n79 VSS.n75 0.2381
R1122 VSS.n83 VSS.n79 0.2381
R1123 VSS.n63 VSS.n62 0.236975
R1124 VSS.n130 VSS.n75 0.236975
R1125 VSS.n20 VSS.t177 0.20525
R1126 VSS.n20 VSS.t157 0.20525
R1127 VSS.n18 VSS.t89 0.20525
R1128 VSS.n18 VSS.t179 0.20525
R1129 VSS.n16 VSS.t201 0.20525
R1130 VSS.n16 VSS.t91 0.20525
R1131 VSS.n14 VSS.t85 0.20525
R1132 VSS.n14 VSS.t203 0.20525
R1133 VSS.n12 VSS.t209 0.20525
R1134 VSS.n12 VSS.t87 0.20525
R1135 VSS.n10 VSS.t59 0.20525
R1136 VSS.n10 VSS.t211 0.20525
R1137 VSS.n8 VSS.t1 0.20525
R1138 VSS.n8 VSS.t61 0.20525
R1139 VSS.n7 VSS.t195 0.20525
R1140 VSS.n7 VSS.t3 0.20525
R1141 VSS.n32 VSS.t191 0.20525
R1142 VSS.n32 VSS.t197 0.20525
R1143 VSS.n30 VSS.t185 0.20525
R1144 VSS.n30 VSS.t183 0.20525
R1145 VSS.n28 VSS.t77 0.20525
R1146 VSS.n28 VSS.t75 0.20525
R1147 VSS.n26 VSS.t161 0.20525
R1148 VSS.n26 VSS.t159 0.20525
R1149 VSS.n24 VSS.t165 0.20525
R1150 VSS.n24 VSS.t163 0.20525
R1151 VSS.n23 VSS.t169 0.20525
R1152 VSS.n23 VSS.t167 0.20525
R1153 VSS.n40 VSS.t21 0.20525
R1154 VSS.n40 VSS.t65 0.20525
R1155 VSS.n38 VSS.t5 0.20525
R1156 VSS.n38 VSS.t23 0.20525
R1157 VSS.n36 VSS.t35 0.20525
R1158 VSS.n36 VSS.t7 0.20525
R1159 VSS.n35 VSS.t63 0.20525
R1160 VSS.n35 VSS.t37 0.20525
R1161 VSS.n48 VSS.t55 0.20525
R1162 VSS.n48 VSS.t155 0.20525
R1163 VSS.n46 VSS.t45 0.20525
R1164 VSS.n46 VSS.t223 0.20525
R1165 VSS.n44 VSS.t205 0.20525
R1166 VSS.n44 VSS.t207 0.20525
R1167 VSS.n43 VSS.t175 0.20525
R1168 VSS.n43 VSS.t43 0.20525
R1169 VSS.n52 VSS.t121 0.20525
R1170 VSS.n52 VSS.t123 0.20525
R1171 VSS.n51 VSS.t109 0.20525
R1172 VSS.n51 VSS.t119 0.20525
R1173 VSS.n56 VSS.t131 0.20525
R1174 VSS.n56 VSS.t133 0.20525
R1175 VSS.n55 VSS.t135 0.20525
R1176 VSS.n55 VSS.t137 0.20525
R1177 VSS.n60 VSS.t115 0.20525
R1178 VSS.n60 VSS.t117 0.20525
R1179 VSS.n59 VSS.t111 0.20525
R1180 VSS.n59 VSS.t113 0.20525
R1181 VSS.n125 VSS.t71 0.20525
R1182 VSS.n125 VSS.t83 0.20525
R1183 VSS.n123 VSS.t29 0.20525
R1184 VSS.n123 VSS.t73 0.20525
R1185 VSS.n121 VSS.t9 0.20525
R1186 VSS.n121 VSS.t31 0.20525
R1187 VSS.n119 VSS.t39 0.20525
R1188 VSS.n119 VSS.t11 0.20525
R1189 VSS.n117 VSS.t79 0.20525
R1190 VSS.n117 VSS.t41 0.20525
R1191 VSS.n115 VSS.t67 0.20525
R1192 VSS.n115 VSS.t81 0.20525
R1193 VSS.n113 VSS.t25 0.20525
R1194 VSS.n113 VSS.t69 0.20525
R1195 VSS.n112 VSS.t199 0.20525
R1196 VSS.n112 VSS.t27 0.20525
R1197 VSS.n109 VSS.t13 0.20525
R1198 VSS.n109 VSS.t213 0.20525
R1199 VSS.n107 VSS.t173 0.20525
R1200 VSS.n107 VSS.t171 0.20525
R1201 VSS.n105 VSS.t217 0.20525
R1202 VSS.n105 VSS.t215 0.20525
R1203 VSS.n103 VSS.t145 0.20525
R1204 VSS.n103 VSS.t143 0.20525
R1205 VSS.n101 VSS.t221 0.20525
R1206 VSS.n101 VSS.t219 0.20525
R1207 VSS.n100 VSS.t141 0.20525
R1208 VSS.n100 VSS.t139 0.20525
R1209 VSS.n97 VSS.t53 0.20525
R1210 VSS.n97 VSS.t51 0.20525
R1211 VSS.n95 VSS.t127 0.20525
R1212 VSS.n95 VSS.t125 0.20525
R1213 VSS.n93 VSS.t17 0.20525
R1214 VSS.n93 VSS.t15 0.20525
R1215 VSS.n92 VSS.t49 0.20525
R1216 VSS.n92 VSS.t47 0.20525
R1217 VSS.n89 VSS.t193 0.20525
R1218 VSS.n89 VSS.t189 0.20525
R1219 VSS.n87 VSS.t19 0.20525
R1220 VSS.n87 VSS.t187 0.20525
R1221 VSS.n85 VSS.t57 0.20525
R1222 VSS.n85 VSS.t181 0.20525
R1223 VSS.n84 VSS.t33 0.20525
R1224 VSS.n84 VSS.t129 0.20525
R1225 VSS.n81 VSS.t105 0.20525
R1226 VSS.n81 VSS.t107 0.20525
R1227 VSS.n80 VSS.t93 0.20525
R1228 VSS.n80 VSS.t103 0.20525
R1229 VSS.n77 VSS.t147 0.20525
R1230 VSS.n77 VSS.t151 0.20525
R1231 VSS.n76 VSS.t153 0.20525
R1232 VSS.n76 VSS.t149 0.20525
R1233 VSS.n73 VSS.t99 0.20525
R1234 VSS.n73 VSS.t101 0.20525
R1235 VSS.n72 VSS.t95 0.20525
R1236 VSS.n72 VSS.t97 0.20525
R1237 VSS.n22 VSS.n6 0.201161
R1238 VSS.n128 VSS.n127 0.201161
R1239 VSS.n11 VSS.n9 0.189974
R1240 VSS.n13 VSS.n11 0.189974
R1241 VSS.n15 VSS.n13 0.189974
R1242 VSS.n17 VSS.n15 0.189974
R1243 VSS.n19 VSS.n17 0.189974
R1244 VSS.n21 VSS.n19 0.189974
R1245 VSS.n27 VSS.n25 0.189974
R1246 VSS.n29 VSS.n27 0.189974
R1247 VSS.n31 VSS.n29 0.189974
R1248 VSS.n33 VSS.n31 0.189974
R1249 VSS.n39 VSS.n37 0.189974
R1250 VSS.n41 VSS.n39 0.189974
R1251 VSS.n47 VSS.n45 0.189974
R1252 VSS.n49 VSS.n47 0.189974
R1253 VSS.n116 VSS.n114 0.189974
R1254 VSS.n118 VSS.n116 0.189974
R1255 VSS.n120 VSS.n118 0.189974
R1256 VSS.n122 VSS.n120 0.189974
R1257 VSS.n124 VSS.n122 0.189974
R1258 VSS.n126 VSS.n124 0.189974
R1259 VSS.n104 VSS.n102 0.189974
R1260 VSS.n106 VSS.n104 0.189974
R1261 VSS.n108 VSS.n106 0.189974
R1262 VSS.n110 VSS.n108 0.189974
R1263 VSS.n96 VSS.n94 0.189974
R1264 VSS.n98 VSS.n96 0.189974
R1265 VSS.n88 VSS.n86 0.189974
R1266 VSS.n90 VSS.n88 0.189974
R1267 VSS.n138 VSS.n0 0.020105
R1268 VSS.n65 VSS.n5 0.00725
R1269 VSS.n63 VSS.n5 0.00725
R1270 VSS.n131 VSS.n71 0.00725
R1271 VSS.n131 VSS.n130 0.00725
R1272 VSS.n137 VSS.n136 0.0054955
R1273 VSS.n137 VSS.n1 0.0054955
R1274 a_14540_6400.n73 a_14540_6400.t39 113.632
R1275 a_14540_6400.n83 a_14540_6400.t24 113.632
R1276 a_14540_6400.n20 a_14540_6400.t71 113.632
R1277 a_14540_6400.n42 a_14540_6400.t40 113.632
R1278 a_14540_6400.n92 a_14540_6400.t31 109.174
R1279 a_14540_6400.n93 a_14540_6400.t32 109.174
R1280 a_14540_6400.n74 a_14540_6400.t38 109.174
R1281 a_14540_6400.n75 a_14540_6400.t37 109.174
R1282 a_14540_6400.n76 a_14540_6400.t36 109.174
R1283 a_14540_6400.n77 a_14540_6400.t35 109.174
R1284 a_14540_6400.n78 a_14540_6400.t34 109.174
R1285 a_14540_6400.n79 a_14540_6400.t33 109.174
R1286 a_14540_6400.n91 a_14540_6400.t30 109.174
R1287 a_14540_6400.n80 a_14540_6400.t29 109.174
R1288 a_14540_6400.n87 a_14540_6400.t28 109.174
R1289 a_14540_6400.n86 a_14540_6400.t27 109.174
R1290 a_14540_6400.n85 a_14540_6400.t26 109.174
R1291 a_14540_6400.n82 a_14540_6400.t25 109.174
R1292 a_14540_6400.n63 a_14540_6400.t55 109.174
R1293 a_14540_6400.n64 a_14540_6400.t56 109.174
R1294 a_14540_6400.n21 a_14540_6400.t70 109.174
R1295 a_14540_6400.n22 a_14540_6400.t69 109.174
R1296 a_14540_6400.n23 a_14540_6400.t68 109.174
R1297 a_14540_6400.n24 a_14540_6400.t67 109.174
R1298 a_14540_6400.n25 a_14540_6400.t66 109.174
R1299 a_14540_6400.n26 a_14540_6400.t65 109.174
R1300 a_14540_6400.n27 a_14540_6400.t64 109.174
R1301 a_14540_6400.n28 a_14540_6400.t63 109.174
R1302 a_14540_6400.n29 a_14540_6400.t62 109.174
R1303 a_14540_6400.n30 a_14540_6400.t61 109.174
R1304 a_14540_6400.n31 a_14540_6400.t60 109.174
R1305 a_14540_6400.n32 a_14540_6400.t59 109.174
R1306 a_14540_6400.n33 a_14540_6400.t58 109.174
R1307 a_14540_6400.n34 a_14540_6400.t57 109.174
R1308 a_14540_6400.n62 a_14540_6400.t54 109.174
R1309 a_14540_6400.n35 a_14540_6400.t53 109.174
R1310 a_14540_6400.n58 a_14540_6400.t52 109.174
R1311 a_14540_6400.n57 a_14540_6400.t51 109.174
R1312 a_14540_6400.n56 a_14540_6400.t50 109.174
R1313 a_14540_6400.n37 a_14540_6400.t49 109.174
R1314 a_14540_6400.n52 a_14540_6400.t48 109.174
R1315 a_14540_6400.n51 a_14540_6400.t47 109.174
R1316 a_14540_6400.n50 a_14540_6400.t46 109.174
R1317 a_14540_6400.n39 a_14540_6400.t45 109.174
R1318 a_14540_6400.n46 a_14540_6400.t44 109.174
R1319 a_14540_6400.n45 a_14540_6400.t43 109.174
R1320 a_14540_6400.n44 a_14540_6400.t42 109.174
R1321 a_14540_6400.n41 a_14540_6400.t41 109.174
R1322 a_14540_6400.n92 a_14540_6400.n67 18.4942
R1323 a_14540_6400.n94 a_14540_6400.n93 18.4942
R1324 a_14540_6400.n75 a_14540_6400.n72 18.4942
R1325 a_14540_6400.n76 a_14540_6400.n71 18.4942
R1326 a_14540_6400.n77 a_14540_6400.n70 18.4942
R1327 a_14540_6400.n78 a_14540_6400.n69 18.4942
R1328 a_14540_6400.n79 a_14540_6400.n68 18.4942
R1329 a_14540_6400.n91 a_14540_6400.n90 18.4942
R1330 a_14540_6400.n89 a_14540_6400.n80 18.4942
R1331 a_14540_6400.n88 a_14540_6400.n87 18.4942
R1332 a_14540_6400.n86 a_14540_6400.n81 18.4942
R1333 a_14540_6400.n85 a_14540_6400.n84 18.4942
R1334 a_14540_6400.n63 a_14540_6400.n6 18.4942
R1335 a_14540_6400.n65 a_14540_6400.n64 18.4942
R1336 a_14540_6400.n22 a_14540_6400.n19 18.4942
R1337 a_14540_6400.n23 a_14540_6400.n18 18.4942
R1338 a_14540_6400.n24 a_14540_6400.n17 18.4942
R1339 a_14540_6400.n25 a_14540_6400.n16 18.4942
R1340 a_14540_6400.n26 a_14540_6400.n15 18.4942
R1341 a_14540_6400.n27 a_14540_6400.n14 18.4942
R1342 a_14540_6400.n28 a_14540_6400.n13 18.4942
R1343 a_14540_6400.n29 a_14540_6400.n12 18.4942
R1344 a_14540_6400.n30 a_14540_6400.n11 18.4942
R1345 a_14540_6400.n31 a_14540_6400.n10 18.4942
R1346 a_14540_6400.n32 a_14540_6400.n9 18.4942
R1347 a_14540_6400.n33 a_14540_6400.n8 18.4942
R1348 a_14540_6400.n34 a_14540_6400.n7 18.4942
R1349 a_14540_6400.n62 a_14540_6400.n61 18.4942
R1350 a_14540_6400.n60 a_14540_6400.n35 18.4942
R1351 a_14540_6400.n59 a_14540_6400.n58 18.4942
R1352 a_14540_6400.n57 a_14540_6400.n36 18.4942
R1353 a_14540_6400.n56 a_14540_6400.n55 18.4942
R1354 a_14540_6400.n54 a_14540_6400.n37 18.4942
R1355 a_14540_6400.n53 a_14540_6400.n52 18.4942
R1356 a_14540_6400.n51 a_14540_6400.n38 18.4942
R1357 a_14540_6400.n50 a_14540_6400.n49 18.4942
R1358 a_14540_6400.n48 a_14540_6400.n39 18.4942
R1359 a_14540_6400.n47 a_14540_6400.n46 18.4942
R1360 a_14540_6400.n45 a_14540_6400.n40 18.4942
R1361 a_14540_6400.n44 a_14540_6400.n43 18.4942
R1362 a_14540_6400.n108 a_14540_6400.n96 16.0141
R1363 a_14540_6400.n92 a_14540_6400.n91 11.6805
R1364 a_14540_6400.n93 a_14540_6400.n92 11.6805
R1365 a_14540_6400.n75 a_14540_6400.n74 11.6805
R1366 a_14540_6400.n76 a_14540_6400.n75 11.6805
R1367 a_14540_6400.n77 a_14540_6400.n76 11.6805
R1368 a_14540_6400.n78 a_14540_6400.n77 11.6805
R1369 a_14540_6400.n79 a_14540_6400.n78 11.6805
R1370 a_14540_6400.n93 a_14540_6400.n79 11.6805
R1371 a_14540_6400.n91 a_14540_6400.n80 11.6805
R1372 a_14540_6400.n87 a_14540_6400.n80 11.6805
R1373 a_14540_6400.n87 a_14540_6400.n86 11.6805
R1374 a_14540_6400.n86 a_14540_6400.n85 11.6805
R1375 a_14540_6400.n85 a_14540_6400.n82 11.6805
R1376 a_14540_6400.n63 a_14540_6400.n62 11.6805
R1377 a_14540_6400.n64 a_14540_6400.n63 11.6805
R1378 a_14540_6400.n22 a_14540_6400.n21 11.6805
R1379 a_14540_6400.n23 a_14540_6400.n22 11.6805
R1380 a_14540_6400.n24 a_14540_6400.n23 11.6805
R1381 a_14540_6400.n25 a_14540_6400.n24 11.6805
R1382 a_14540_6400.n26 a_14540_6400.n25 11.6805
R1383 a_14540_6400.n27 a_14540_6400.n26 11.6805
R1384 a_14540_6400.n28 a_14540_6400.n27 11.6805
R1385 a_14540_6400.n29 a_14540_6400.n28 11.6805
R1386 a_14540_6400.n30 a_14540_6400.n29 11.6805
R1387 a_14540_6400.n31 a_14540_6400.n30 11.6805
R1388 a_14540_6400.n32 a_14540_6400.n31 11.6805
R1389 a_14540_6400.n33 a_14540_6400.n32 11.6805
R1390 a_14540_6400.n34 a_14540_6400.n33 11.6805
R1391 a_14540_6400.n64 a_14540_6400.n34 11.6805
R1392 a_14540_6400.n62 a_14540_6400.n35 11.6805
R1393 a_14540_6400.n58 a_14540_6400.n35 11.6805
R1394 a_14540_6400.n58 a_14540_6400.n57 11.6805
R1395 a_14540_6400.n57 a_14540_6400.n56 11.6805
R1396 a_14540_6400.n56 a_14540_6400.n37 11.6805
R1397 a_14540_6400.n52 a_14540_6400.n37 11.6805
R1398 a_14540_6400.n52 a_14540_6400.n51 11.6805
R1399 a_14540_6400.n51 a_14540_6400.n50 11.6805
R1400 a_14540_6400.n50 a_14540_6400.n39 11.6805
R1401 a_14540_6400.n46 a_14540_6400.n39 11.6805
R1402 a_14540_6400.n46 a_14540_6400.n45 11.6805
R1403 a_14540_6400.n45 a_14540_6400.n44 11.6805
R1404 a_14540_6400.n44 a_14540_6400.n41 11.6805
R1405 a_14540_6400.n96 a_14540_6400.n66 10.688
R1406 a_14540_6400.n96 a_14540_6400.n95 9.24157
R1407 a_14540_6400.n84 a_14540_6400.n83 7.17687
R1408 a_14540_6400.n73 a_14540_6400.n72 7.17687
R1409 a_14540_6400.n43 a_14540_6400.n42 7.17687
R1410 a_14540_6400.n20 a_14540_6400.n19 7.17687
R1411 a_14540_6400.n109 a_14540_6400.n108 6.5392
R1412 a_14540_6400.n98 a_14540_6400.t23 5.7796
R1413 a_14540_6400.n1 a_14540_6400.t10 5.73764
R1414 a_14540_6400.n107 a_14540_6400.t19 5.59012
R1415 a_14540_6400.n109 a_14540_6400.t13 5.54817
R1416 a_14540_6400.n98 a_14540_6400.n97 5.38537
R1417 a_14540_6400.n100 a_14540_6400.n99 5.38537
R1418 a_14540_6400.n102 a_14540_6400.n101 5.38537
R1419 a_14540_6400.n104 a_14540_6400.n103 5.38537
R1420 a_14540_6400.n106 a_14540_6400.n105 5.38537
R1421 a_14540_6400.n113 a_14540_6400.n112 5.32067
R1422 a_14540_6400.n1 a_14540_6400.n0 5.32067
R1423 a_14540_6400.n3 a_14540_6400.n2 5.32067
R1424 a_14540_6400.n5 a_14540_6400.n4 5.32067
R1425 a_14540_6400.n111 a_14540_6400.n110 5.32067
R1426 a_14540_6400.n108 a_14540_6400.n107 4.61063
R1427 a_14540_6400.n74 a_14540_6400.n73 4.42851
R1428 a_14540_6400.n83 a_14540_6400.n82 4.42851
R1429 a_14540_6400.n21 a_14540_6400.n20 4.42851
R1430 a_14540_6400.n42 a_14540_6400.n41 4.42851
R1431 a_14540_6400.t0 a_14540_6400.n113 0.228
R1432 a_14540_6400.n113 a_14540_6400.t5 0.228
R1433 a_14540_6400.n0 a_14540_6400.t6 0.228
R1434 a_14540_6400.n0 a_14540_6400.t11 0.228
R1435 a_14540_6400.n2 a_14540_6400.t8 0.228
R1436 a_14540_6400.n2 a_14540_6400.t7 0.228
R1437 a_14540_6400.n4 a_14540_6400.t4 0.228
R1438 a_14540_6400.n4 a_14540_6400.t9 0.228
R1439 a_14540_6400.n110 a_14540_6400.t12 0.228
R1440 a_14540_6400.n110 a_14540_6400.t1 0.228
R1441 a_14540_6400.n97 a_14540_6400.t20 0.20525
R1442 a_14540_6400.n97 a_14540_6400.t22 0.20525
R1443 a_14540_6400.n99 a_14540_6400.t2 0.20525
R1444 a_14540_6400.n99 a_14540_6400.t21 0.20525
R1445 a_14540_6400.n101 a_14540_6400.t14 0.20525
R1446 a_14540_6400.n101 a_14540_6400.t3 0.20525
R1447 a_14540_6400.n103 a_14540_6400.t16 0.20525
R1448 a_14540_6400.n103 a_14540_6400.t15 0.20525
R1449 a_14540_6400.n105 a_14540_6400.t18 0.20525
R1450 a_14540_6400.n105 a_14540_6400.t17 0.20525
R1451 a_14540_6400.n111 a_14540_6400.n109 0.189974
R1452 a_14540_6400.n112 a_14540_6400.n111 0.189974
R1453 a_14540_6400.n112 a_14540_6400.n5 0.189974
R1454 a_14540_6400.n5 a_14540_6400.n3 0.189974
R1455 a_14540_6400.n3 a_14540_6400.n1 0.189974
R1456 a_14540_6400.n107 a_14540_6400.n106 0.189974
R1457 a_14540_6400.n106 a_14540_6400.n104 0.189974
R1458 a_14540_6400.n104 a_14540_6400.n102 0.189974
R1459 a_14540_6400.n102 a_14540_6400.n100 0.189974
R1460 a_14540_6400.n100 a_14540_6400.n98 0.189974
R1461 a_14540_6400.n90 a_14540_6400.n67 0.1205
R1462 a_14540_6400.n90 a_14540_6400.n89 0.1205
R1463 a_14540_6400.n89 a_14540_6400.n88 0.1205
R1464 a_14540_6400.n88 a_14540_6400.n81 0.1205
R1465 a_14540_6400.n84 a_14540_6400.n81 0.1205
R1466 a_14540_6400.n72 a_14540_6400.n71 0.1205
R1467 a_14540_6400.n71 a_14540_6400.n70 0.1205
R1468 a_14540_6400.n70 a_14540_6400.n69 0.1205
R1469 a_14540_6400.n69 a_14540_6400.n68 0.1205
R1470 a_14540_6400.n94 a_14540_6400.n68 0.1205
R1471 a_14540_6400.n61 a_14540_6400.n6 0.1205
R1472 a_14540_6400.n61 a_14540_6400.n60 0.1205
R1473 a_14540_6400.n60 a_14540_6400.n59 0.1205
R1474 a_14540_6400.n59 a_14540_6400.n36 0.1205
R1475 a_14540_6400.n55 a_14540_6400.n36 0.1205
R1476 a_14540_6400.n55 a_14540_6400.n54 0.1205
R1477 a_14540_6400.n54 a_14540_6400.n53 0.1205
R1478 a_14540_6400.n53 a_14540_6400.n38 0.1205
R1479 a_14540_6400.n49 a_14540_6400.n38 0.1205
R1480 a_14540_6400.n49 a_14540_6400.n48 0.1205
R1481 a_14540_6400.n48 a_14540_6400.n47 0.1205
R1482 a_14540_6400.n47 a_14540_6400.n40 0.1205
R1483 a_14540_6400.n43 a_14540_6400.n40 0.1205
R1484 a_14540_6400.n19 a_14540_6400.n18 0.1205
R1485 a_14540_6400.n18 a_14540_6400.n17 0.1205
R1486 a_14540_6400.n17 a_14540_6400.n16 0.1205
R1487 a_14540_6400.n16 a_14540_6400.n15 0.1205
R1488 a_14540_6400.n15 a_14540_6400.n14 0.1205
R1489 a_14540_6400.n14 a_14540_6400.n13 0.1205
R1490 a_14540_6400.n13 a_14540_6400.n12 0.1205
R1491 a_14540_6400.n12 a_14540_6400.n11 0.1205
R1492 a_14540_6400.n11 a_14540_6400.n10 0.1205
R1493 a_14540_6400.n10 a_14540_6400.n9 0.1205
R1494 a_14540_6400.n9 a_14540_6400.n8 0.1205
R1495 a_14540_6400.n8 a_14540_6400.n7 0.1205
R1496 a_14540_6400.n65 a_14540_6400.n7 0.1205
R1497 a_14540_6400.n95 a_14540_6400.n67 0.0485
R1498 a_14540_6400.n95 a_14540_6400.n94 0.0485
R1499 a_14540_6400.n66 a_14540_6400.n6 0.0485
R1500 a_14540_6400.n66 a_14540_6400.n65 0.0485
R1501 a_6924_6400.n28 a_6924_6400.t19 113.632
R1502 a_6924_6400.n34 a_6924_6400.t8 113.632
R1503 a_6924_6400.n7 a_6924_6400.t31 113.632
R1504 a_6924_6400.n13 a_6924_6400.t20 113.632
R1505 a_6924_6400.n41 a_6924_6400.t13 109.174
R1506 a_6924_6400.n42 a_6924_6400.t14 109.174
R1507 a_6924_6400.n29 a_6924_6400.t18 109.174
R1508 a_6924_6400.n30 a_6924_6400.t17 109.174
R1509 a_6924_6400.n31 a_6924_6400.t16 109.174
R1510 a_6924_6400.n32 a_6924_6400.t15 109.174
R1511 a_6924_6400.n40 a_6924_6400.t12 109.174
R1512 a_6924_6400.n33 a_6924_6400.t11 109.174
R1513 a_6924_6400.n36 a_6924_6400.t10 109.174
R1514 a_6924_6400.n35 a_6924_6400.t9 109.174
R1515 a_6924_6400.n20 a_6924_6400.t25 109.174
R1516 a_6924_6400.n21 a_6924_6400.t26 109.174
R1517 a_6924_6400.n8 a_6924_6400.t30 109.174
R1518 a_6924_6400.n9 a_6924_6400.t29 109.174
R1519 a_6924_6400.n10 a_6924_6400.t28 109.174
R1520 a_6924_6400.n11 a_6924_6400.t27 109.174
R1521 a_6924_6400.n19 a_6924_6400.t24 109.174
R1522 a_6924_6400.n12 a_6924_6400.t23 109.174
R1523 a_6924_6400.n15 a_6924_6400.t22 109.174
R1524 a_6924_6400.n14 a_6924_6400.t21 109.174
R1525 a_6924_6400.n41 a_6924_6400.n24 18.4942
R1526 a_6924_6400.n43 a_6924_6400.n42 18.4942
R1527 a_6924_6400.n30 a_6924_6400.n27 18.4942
R1528 a_6924_6400.n31 a_6924_6400.n26 18.4942
R1529 a_6924_6400.n32 a_6924_6400.n25 18.4942
R1530 a_6924_6400.n40 a_6924_6400.n39 18.4942
R1531 a_6924_6400.n38 a_6924_6400.n33 18.4942
R1532 a_6924_6400.n37 a_6924_6400.n36 18.4942
R1533 a_6924_6400.n20 a_6924_6400.n3 18.4942
R1534 a_6924_6400.n22 a_6924_6400.n21 18.4942
R1535 a_6924_6400.n9 a_6924_6400.n6 18.4942
R1536 a_6924_6400.n10 a_6924_6400.n5 18.4942
R1537 a_6924_6400.n11 a_6924_6400.n4 18.4942
R1538 a_6924_6400.n19 a_6924_6400.n18 18.4942
R1539 a_6924_6400.n17 a_6924_6400.n12 18.4942
R1540 a_6924_6400.n16 a_6924_6400.n15 18.4942
R1541 a_6924_6400.n46 a_6924_6400.n45 17.906
R1542 a_6924_6400.n41 a_6924_6400.n40 11.6805
R1543 a_6924_6400.n42 a_6924_6400.n41 11.6805
R1544 a_6924_6400.n30 a_6924_6400.n29 11.6805
R1545 a_6924_6400.n31 a_6924_6400.n30 11.6805
R1546 a_6924_6400.n32 a_6924_6400.n31 11.6805
R1547 a_6924_6400.n42 a_6924_6400.n32 11.6805
R1548 a_6924_6400.n40 a_6924_6400.n33 11.6805
R1549 a_6924_6400.n36 a_6924_6400.n33 11.6805
R1550 a_6924_6400.n36 a_6924_6400.n35 11.6805
R1551 a_6924_6400.n20 a_6924_6400.n19 11.6805
R1552 a_6924_6400.n21 a_6924_6400.n20 11.6805
R1553 a_6924_6400.n9 a_6924_6400.n8 11.6805
R1554 a_6924_6400.n10 a_6924_6400.n9 11.6805
R1555 a_6924_6400.n11 a_6924_6400.n10 11.6805
R1556 a_6924_6400.n21 a_6924_6400.n11 11.6805
R1557 a_6924_6400.n19 a_6924_6400.n12 11.6805
R1558 a_6924_6400.n15 a_6924_6400.n12 11.6805
R1559 a_6924_6400.n15 a_6924_6400.n14 11.6805
R1560 a_6924_6400.n45 a_6924_6400.n23 10.013
R1561 a_6924_6400.n45 a_6924_6400.n44 9.91657
R1562 a_6924_6400.n37 a_6924_6400.n34 7.17687
R1563 a_6924_6400.n28 a_6924_6400.n27 7.17687
R1564 a_6924_6400.n16 a_6924_6400.n13 7.17687
R1565 a_6924_6400.n7 a_6924_6400.n6 7.17687
R1566 a_6924_6400.n46 a_6924_6400.n2 6.5392
R1567 a_6924_6400.t3 a_6924_6400.n49 5.7796
R1568 a_6924_6400.n1 a_6924_6400.t7 5.73764
R1569 a_6924_6400.n47 a_6924_6400.t0 5.59012
R1570 a_6924_6400.n2 a_6924_6400.t4 5.54817
R1571 a_6924_6400.n49 a_6924_6400.n48 5.38537
R1572 a_6924_6400.n1 a_6924_6400.n0 5.32067
R1573 a_6924_6400.n47 a_6924_6400.n46 4.61063
R1574 a_6924_6400.n29 a_6924_6400.n28 4.42851
R1575 a_6924_6400.n35 a_6924_6400.n34 4.42851
R1576 a_6924_6400.n8 a_6924_6400.n7 4.42851
R1577 a_6924_6400.n14 a_6924_6400.n13 4.42851
R1578 a_6924_6400.n0 a_6924_6400.t5 0.228
R1579 a_6924_6400.n0 a_6924_6400.t6 0.228
R1580 a_6924_6400.n48 a_6924_6400.t1 0.20525
R1581 a_6924_6400.n48 a_6924_6400.t2 0.20525
R1582 a_6924_6400.n49 a_6924_6400.n47 0.189974
R1583 a_6924_6400.n2 a_6924_6400.n1 0.189974
R1584 a_6924_6400.n39 a_6924_6400.n24 0.1205
R1585 a_6924_6400.n39 a_6924_6400.n38 0.1205
R1586 a_6924_6400.n38 a_6924_6400.n37 0.1205
R1587 a_6924_6400.n27 a_6924_6400.n26 0.1205
R1588 a_6924_6400.n26 a_6924_6400.n25 0.1205
R1589 a_6924_6400.n43 a_6924_6400.n25 0.1205
R1590 a_6924_6400.n18 a_6924_6400.n3 0.1205
R1591 a_6924_6400.n18 a_6924_6400.n17 0.1205
R1592 a_6924_6400.n17 a_6924_6400.n16 0.1205
R1593 a_6924_6400.n6 a_6924_6400.n5 0.1205
R1594 a_6924_6400.n5 a_6924_6400.n4 0.1205
R1595 a_6924_6400.n22 a_6924_6400.n4 0.1205
R1596 a_6924_6400.n44 a_6924_6400.n24 0.0485
R1597 a_6924_6400.n44 a_6924_6400.n43 0.0485
R1598 a_6924_6400.n23 a_6924_6400.n3 0.0485
R1599 a_6924_6400.n23 a_6924_6400.n22 0.0485
R1600 a_4812_6400.n18 a_4812_6400.t15 113.632
R1601 a_4812_6400.n22 a_4812_6400.t8 113.632
R1602 a_4812_6400.n5 a_4812_6400.t23 113.632
R1603 a_4812_6400.n9 a_4812_6400.t16 113.632
R1604 a_4812_6400.n25 a_4812_6400.t11 109.174
R1605 a_4812_6400.n26 a_4812_6400.t12 109.174
R1606 a_4812_6400.n19 a_4812_6400.t14 109.174
R1607 a_4812_6400.n20 a_4812_6400.t13 109.174
R1608 a_4812_6400.n24 a_4812_6400.t10 109.174
R1609 a_4812_6400.n21 a_4812_6400.t9 109.174
R1610 a_4812_6400.n12 a_4812_6400.t19 109.174
R1611 a_4812_6400.n13 a_4812_6400.t20 109.174
R1612 a_4812_6400.n6 a_4812_6400.t22 109.174
R1613 a_4812_6400.n7 a_4812_6400.t21 109.174
R1614 a_4812_6400.n11 a_4812_6400.t18 109.174
R1615 a_4812_6400.n8 a_4812_6400.t17 109.174
R1616 a_4812_6400.n25 a_4812_6400.n16 18.4942
R1617 a_4812_6400.n27 a_4812_6400.n26 18.4942
R1618 a_4812_6400.n20 a_4812_6400.n17 18.4942
R1619 a_4812_6400.n24 a_4812_6400.n23 18.4942
R1620 a_4812_6400.n12 a_4812_6400.n3 18.4942
R1621 a_4812_6400.n14 a_4812_6400.n13 18.4942
R1622 a_4812_6400.n7 a_4812_6400.n4 18.4942
R1623 a_4812_6400.n11 a_4812_6400.n10 18.4942
R1624 a_4812_6400.n30 a_4812_6400.n29 17.3044
R1625 a_4812_6400.n25 a_4812_6400.n24 11.6805
R1626 a_4812_6400.n26 a_4812_6400.n25 11.6805
R1627 a_4812_6400.n20 a_4812_6400.n19 11.6805
R1628 a_4812_6400.n26 a_4812_6400.n20 11.6805
R1629 a_4812_6400.n24 a_4812_6400.n21 11.6805
R1630 a_4812_6400.n12 a_4812_6400.n11 11.6805
R1631 a_4812_6400.n13 a_4812_6400.n12 11.6805
R1632 a_4812_6400.n7 a_4812_6400.n6 11.6805
R1633 a_4812_6400.n13 a_4812_6400.n7 11.6805
R1634 a_4812_6400.n11 a_4812_6400.n8 11.6805
R1635 a_4812_6400.n29 a_4812_6400.n15 10.3505
R1636 a_4812_6400.n29 a_4812_6400.n28 9.57907
R1637 a_4812_6400.n23 a_4812_6400.n22 7.17687
R1638 a_4812_6400.n18 a_4812_6400.n17 7.17687
R1639 a_4812_6400.n10 a_4812_6400.n9 7.17687
R1640 a_4812_6400.n5 a_4812_6400.n4 7.17687
R1641 a_4812_6400.n30 a_4812_6400.n2 6.5392
R1642 a_4812_6400.t3 a_4812_6400.n33 5.7796
R1643 a_4812_6400.n1 a_4812_6400.t7 5.73764
R1644 a_4812_6400.n31 a_4812_6400.t0 5.59012
R1645 a_4812_6400.n2 a_4812_6400.t4 5.54817
R1646 a_4812_6400.n33 a_4812_6400.n32 5.38537
R1647 a_4812_6400.n1 a_4812_6400.n0 5.32067
R1648 a_4812_6400.n31 a_4812_6400.n30 4.61063
R1649 a_4812_6400.n19 a_4812_6400.n18 4.42851
R1650 a_4812_6400.n22 a_4812_6400.n21 4.42851
R1651 a_4812_6400.n6 a_4812_6400.n5 4.42851
R1652 a_4812_6400.n9 a_4812_6400.n8 4.42851
R1653 a_4812_6400.n0 a_4812_6400.t5 0.228
R1654 a_4812_6400.n0 a_4812_6400.t6 0.228
R1655 a_4812_6400.n32 a_4812_6400.t1 0.20525
R1656 a_4812_6400.n32 a_4812_6400.t2 0.20525
R1657 a_4812_6400.n33 a_4812_6400.n31 0.189974
R1658 a_4812_6400.n2 a_4812_6400.n1 0.189974
R1659 a_4812_6400.n23 a_4812_6400.n16 0.1205
R1660 a_4812_6400.n27 a_4812_6400.n17 0.1205
R1661 a_4812_6400.n10 a_4812_6400.n3 0.1205
R1662 a_4812_6400.n14 a_4812_6400.n4 0.1205
R1663 a_4812_6400.n28 a_4812_6400.n16 0.0485
R1664 a_4812_6400.n28 a_4812_6400.n27 0.0485
R1665 a_4812_6400.n15 a_4812_6400.n3 0.0485
R1666 a_4812_6400.n15 a_4812_6400.n14 0.0485
R1667 a_2700_6400.n18 a_2700_6400.t15 113.632
R1668 a_2700_6400.n22 a_2700_6400.t8 113.632
R1669 a_2700_6400.n5 a_2700_6400.t23 113.632
R1670 a_2700_6400.n9 a_2700_6400.t16 113.632
R1671 a_2700_6400.n25 a_2700_6400.t11 109.174
R1672 a_2700_6400.n26 a_2700_6400.t12 109.174
R1673 a_2700_6400.n19 a_2700_6400.t14 109.174
R1674 a_2700_6400.n20 a_2700_6400.t13 109.174
R1675 a_2700_6400.n24 a_2700_6400.t10 109.174
R1676 a_2700_6400.n21 a_2700_6400.t9 109.174
R1677 a_2700_6400.n12 a_2700_6400.t19 109.174
R1678 a_2700_6400.n13 a_2700_6400.t20 109.174
R1679 a_2700_6400.n6 a_2700_6400.t22 109.174
R1680 a_2700_6400.n7 a_2700_6400.t21 109.174
R1681 a_2700_6400.n11 a_2700_6400.t18 109.174
R1682 a_2700_6400.n8 a_2700_6400.t17 109.174
R1683 a_2700_6400.n25 a_2700_6400.n16 18.4942
R1684 a_2700_6400.n27 a_2700_6400.n26 18.4942
R1685 a_2700_6400.n20 a_2700_6400.n17 18.4942
R1686 a_2700_6400.n24 a_2700_6400.n23 18.4942
R1687 a_2700_6400.n12 a_2700_6400.n3 18.4942
R1688 a_2700_6400.n14 a_2700_6400.n13 18.4942
R1689 a_2700_6400.n7 a_2700_6400.n4 18.4942
R1690 a_2700_6400.n11 a_2700_6400.n10 18.4942
R1691 a_2700_6400.n30 a_2700_6400.n29 17.0158
R1692 a_2700_6400.n25 a_2700_6400.n24 11.6805
R1693 a_2700_6400.n26 a_2700_6400.n25 11.6805
R1694 a_2700_6400.n20 a_2700_6400.n19 11.6805
R1695 a_2700_6400.n26 a_2700_6400.n20 11.6805
R1696 a_2700_6400.n24 a_2700_6400.n21 11.6805
R1697 a_2700_6400.n12 a_2700_6400.n11 11.6805
R1698 a_2700_6400.n13 a_2700_6400.n12 11.6805
R1699 a_2700_6400.n7 a_2700_6400.n6 11.6805
R1700 a_2700_6400.n13 a_2700_6400.n7 11.6805
R1701 a_2700_6400.n11 a_2700_6400.n8 11.6805
R1702 a_2700_6400.n29 a_2700_6400.n15 10.688
R1703 a_2700_6400.n29 a_2700_6400.n28 9.24157
R1704 a_2700_6400.n23 a_2700_6400.n22 7.17687
R1705 a_2700_6400.n18 a_2700_6400.n17 7.17687
R1706 a_2700_6400.n10 a_2700_6400.n9 7.17687
R1707 a_2700_6400.n5 a_2700_6400.n4 7.17687
R1708 a_2700_6400.n30 a_2700_6400.n2 6.5392
R1709 a_2700_6400.t3 a_2700_6400.n33 5.7796
R1710 a_2700_6400.n1 a_2700_6400.t7 5.73764
R1711 a_2700_6400.n31 a_2700_6400.t0 5.59012
R1712 a_2700_6400.n2 a_2700_6400.t4 5.54817
R1713 a_2700_6400.n33 a_2700_6400.n32 5.38537
R1714 a_2700_6400.n1 a_2700_6400.n0 5.32067
R1715 a_2700_6400.n31 a_2700_6400.n30 4.61063
R1716 a_2700_6400.n19 a_2700_6400.n18 4.42851
R1717 a_2700_6400.n22 a_2700_6400.n21 4.42851
R1718 a_2700_6400.n6 a_2700_6400.n5 4.42851
R1719 a_2700_6400.n9 a_2700_6400.n8 4.42851
R1720 a_2700_6400.n0 a_2700_6400.t5 0.228
R1721 a_2700_6400.n0 a_2700_6400.t6 0.228
R1722 a_2700_6400.n32 a_2700_6400.t1 0.20525
R1723 a_2700_6400.n32 a_2700_6400.t2 0.20525
R1724 a_2700_6400.n33 a_2700_6400.n31 0.189974
R1725 a_2700_6400.n2 a_2700_6400.n1 0.189974
R1726 a_2700_6400.n23 a_2700_6400.n16 0.1205
R1727 a_2700_6400.n27 a_2700_6400.n17 0.1205
R1728 a_2700_6400.n10 a_2700_6400.n3 0.1205
R1729 a_2700_6400.n14 a_2700_6400.n4 0.1205
R1730 a_2700_6400.n28 a_2700_6400.n16 0.0485
R1731 a_2700_6400.n28 a_2700_6400.n27 0.0485
R1732 a_2700_6400.n15 a_2700_6400.n3 0.0485
R1733 a_2700_6400.n15 a_2700_6400.n14 0.0485
R1734 a_14540_41600.n78 a_14540_41600.t39 113.632
R1735 a_14540_41600.n88 a_14540_41600.t24 113.632
R1736 a_14540_41600.n25 a_14540_41600.t71 113.632
R1737 a_14540_41600.n47 a_14540_41600.t40 113.632
R1738 a_14540_41600.n97 a_14540_41600.t31 109.174
R1739 a_14540_41600.n98 a_14540_41600.t32 109.174
R1740 a_14540_41600.n79 a_14540_41600.t38 109.174
R1741 a_14540_41600.n80 a_14540_41600.t37 109.174
R1742 a_14540_41600.n81 a_14540_41600.t36 109.174
R1743 a_14540_41600.n82 a_14540_41600.t35 109.174
R1744 a_14540_41600.n83 a_14540_41600.t34 109.174
R1745 a_14540_41600.n84 a_14540_41600.t33 109.174
R1746 a_14540_41600.n96 a_14540_41600.t30 109.174
R1747 a_14540_41600.n85 a_14540_41600.t29 109.174
R1748 a_14540_41600.n92 a_14540_41600.t28 109.174
R1749 a_14540_41600.n91 a_14540_41600.t27 109.174
R1750 a_14540_41600.n90 a_14540_41600.t26 109.174
R1751 a_14540_41600.n87 a_14540_41600.t25 109.174
R1752 a_14540_41600.n68 a_14540_41600.t55 109.174
R1753 a_14540_41600.n69 a_14540_41600.t56 109.174
R1754 a_14540_41600.n26 a_14540_41600.t70 109.174
R1755 a_14540_41600.n27 a_14540_41600.t69 109.174
R1756 a_14540_41600.n28 a_14540_41600.t68 109.174
R1757 a_14540_41600.n29 a_14540_41600.t67 109.174
R1758 a_14540_41600.n30 a_14540_41600.t66 109.174
R1759 a_14540_41600.n31 a_14540_41600.t65 109.174
R1760 a_14540_41600.n32 a_14540_41600.t64 109.174
R1761 a_14540_41600.n33 a_14540_41600.t63 109.174
R1762 a_14540_41600.n34 a_14540_41600.t62 109.174
R1763 a_14540_41600.n35 a_14540_41600.t61 109.174
R1764 a_14540_41600.n36 a_14540_41600.t60 109.174
R1765 a_14540_41600.n37 a_14540_41600.t59 109.174
R1766 a_14540_41600.n38 a_14540_41600.t58 109.174
R1767 a_14540_41600.n39 a_14540_41600.t57 109.174
R1768 a_14540_41600.n67 a_14540_41600.t54 109.174
R1769 a_14540_41600.n40 a_14540_41600.t53 109.174
R1770 a_14540_41600.n63 a_14540_41600.t52 109.174
R1771 a_14540_41600.n62 a_14540_41600.t51 109.174
R1772 a_14540_41600.n61 a_14540_41600.t50 109.174
R1773 a_14540_41600.n42 a_14540_41600.t49 109.174
R1774 a_14540_41600.n57 a_14540_41600.t48 109.174
R1775 a_14540_41600.n56 a_14540_41600.t47 109.174
R1776 a_14540_41600.n55 a_14540_41600.t46 109.174
R1777 a_14540_41600.n44 a_14540_41600.t45 109.174
R1778 a_14540_41600.n51 a_14540_41600.t44 109.174
R1779 a_14540_41600.n50 a_14540_41600.t43 109.174
R1780 a_14540_41600.n49 a_14540_41600.t42 109.174
R1781 a_14540_41600.n46 a_14540_41600.t41 109.174
R1782 a_14540_41600.n97 a_14540_41600.n72 18.4942
R1783 a_14540_41600.n99 a_14540_41600.n98 18.4942
R1784 a_14540_41600.n80 a_14540_41600.n77 18.4942
R1785 a_14540_41600.n81 a_14540_41600.n76 18.4942
R1786 a_14540_41600.n82 a_14540_41600.n75 18.4942
R1787 a_14540_41600.n83 a_14540_41600.n74 18.4942
R1788 a_14540_41600.n84 a_14540_41600.n73 18.4942
R1789 a_14540_41600.n96 a_14540_41600.n95 18.4942
R1790 a_14540_41600.n94 a_14540_41600.n85 18.4942
R1791 a_14540_41600.n93 a_14540_41600.n92 18.4942
R1792 a_14540_41600.n91 a_14540_41600.n86 18.4942
R1793 a_14540_41600.n90 a_14540_41600.n89 18.4942
R1794 a_14540_41600.n68 a_14540_41600.n11 18.4942
R1795 a_14540_41600.n70 a_14540_41600.n69 18.4942
R1796 a_14540_41600.n27 a_14540_41600.n24 18.4942
R1797 a_14540_41600.n28 a_14540_41600.n23 18.4942
R1798 a_14540_41600.n29 a_14540_41600.n22 18.4942
R1799 a_14540_41600.n30 a_14540_41600.n21 18.4942
R1800 a_14540_41600.n31 a_14540_41600.n20 18.4942
R1801 a_14540_41600.n32 a_14540_41600.n19 18.4942
R1802 a_14540_41600.n33 a_14540_41600.n18 18.4942
R1803 a_14540_41600.n34 a_14540_41600.n17 18.4942
R1804 a_14540_41600.n35 a_14540_41600.n16 18.4942
R1805 a_14540_41600.n36 a_14540_41600.n15 18.4942
R1806 a_14540_41600.n37 a_14540_41600.n14 18.4942
R1807 a_14540_41600.n38 a_14540_41600.n13 18.4942
R1808 a_14540_41600.n39 a_14540_41600.n12 18.4942
R1809 a_14540_41600.n67 a_14540_41600.n66 18.4942
R1810 a_14540_41600.n65 a_14540_41600.n40 18.4942
R1811 a_14540_41600.n64 a_14540_41600.n63 18.4942
R1812 a_14540_41600.n62 a_14540_41600.n41 18.4942
R1813 a_14540_41600.n61 a_14540_41600.n60 18.4942
R1814 a_14540_41600.n59 a_14540_41600.n42 18.4942
R1815 a_14540_41600.n58 a_14540_41600.n57 18.4942
R1816 a_14540_41600.n56 a_14540_41600.n43 18.4942
R1817 a_14540_41600.n55 a_14540_41600.n54 18.4942
R1818 a_14540_41600.n53 a_14540_41600.n44 18.4942
R1819 a_14540_41600.n52 a_14540_41600.n51 18.4942
R1820 a_14540_41600.n50 a_14540_41600.n45 18.4942
R1821 a_14540_41600.n49 a_14540_41600.n48 18.4942
R1822 a_14540_41600.n102 a_14540_41600.n101 16.0141
R1823 a_14540_41600.n97 a_14540_41600.n96 11.6805
R1824 a_14540_41600.n98 a_14540_41600.n97 11.6805
R1825 a_14540_41600.n80 a_14540_41600.n79 11.6805
R1826 a_14540_41600.n81 a_14540_41600.n80 11.6805
R1827 a_14540_41600.n82 a_14540_41600.n81 11.6805
R1828 a_14540_41600.n83 a_14540_41600.n82 11.6805
R1829 a_14540_41600.n84 a_14540_41600.n83 11.6805
R1830 a_14540_41600.n98 a_14540_41600.n84 11.6805
R1831 a_14540_41600.n96 a_14540_41600.n85 11.6805
R1832 a_14540_41600.n92 a_14540_41600.n85 11.6805
R1833 a_14540_41600.n92 a_14540_41600.n91 11.6805
R1834 a_14540_41600.n91 a_14540_41600.n90 11.6805
R1835 a_14540_41600.n90 a_14540_41600.n87 11.6805
R1836 a_14540_41600.n68 a_14540_41600.n67 11.6805
R1837 a_14540_41600.n69 a_14540_41600.n68 11.6805
R1838 a_14540_41600.n27 a_14540_41600.n26 11.6805
R1839 a_14540_41600.n28 a_14540_41600.n27 11.6805
R1840 a_14540_41600.n29 a_14540_41600.n28 11.6805
R1841 a_14540_41600.n30 a_14540_41600.n29 11.6805
R1842 a_14540_41600.n31 a_14540_41600.n30 11.6805
R1843 a_14540_41600.n32 a_14540_41600.n31 11.6805
R1844 a_14540_41600.n33 a_14540_41600.n32 11.6805
R1845 a_14540_41600.n34 a_14540_41600.n33 11.6805
R1846 a_14540_41600.n35 a_14540_41600.n34 11.6805
R1847 a_14540_41600.n36 a_14540_41600.n35 11.6805
R1848 a_14540_41600.n37 a_14540_41600.n36 11.6805
R1849 a_14540_41600.n38 a_14540_41600.n37 11.6805
R1850 a_14540_41600.n39 a_14540_41600.n38 11.6805
R1851 a_14540_41600.n69 a_14540_41600.n39 11.6805
R1852 a_14540_41600.n67 a_14540_41600.n40 11.6805
R1853 a_14540_41600.n63 a_14540_41600.n40 11.6805
R1854 a_14540_41600.n63 a_14540_41600.n62 11.6805
R1855 a_14540_41600.n62 a_14540_41600.n61 11.6805
R1856 a_14540_41600.n61 a_14540_41600.n42 11.6805
R1857 a_14540_41600.n57 a_14540_41600.n42 11.6805
R1858 a_14540_41600.n57 a_14540_41600.n56 11.6805
R1859 a_14540_41600.n56 a_14540_41600.n55 11.6805
R1860 a_14540_41600.n55 a_14540_41600.n44 11.6805
R1861 a_14540_41600.n51 a_14540_41600.n44 11.6805
R1862 a_14540_41600.n51 a_14540_41600.n50 11.6805
R1863 a_14540_41600.n50 a_14540_41600.n49 11.6805
R1864 a_14540_41600.n49 a_14540_41600.n46 11.6805
R1865 a_14540_41600.n101 a_14540_41600.n71 10.688
R1866 a_14540_41600.n101 a_14540_41600.n100 9.24157
R1867 a_14540_41600.n89 a_14540_41600.n88 7.17687
R1868 a_14540_41600.n78 a_14540_41600.n77 7.17687
R1869 a_14540_41600.n48 a_14540_41600.n47 7.17687
R1870 a_14540_41600.n25 a_14540_41600.n24 7.17687
R1871 a_14540_41600.n102 a_14540_41600.n10 6.5392
R1872 a_14540_41600.n112 a_14540_41600.t17 5.7796
R1873 a_14540_41600.n1 a_14540_41600.t15 5.73764
R1874 a_14540_41600.n103 a_14540_41600.t2 5.59012
R1875 a_14540_41600.n10 a_14540_41600.t12 5.54817
R1876 a_14540_41600.n113 a_14540_41600.n112 5.38537
R1877 a_14540_41600.n111 a_14540_41600.n110 5.38537
R1878 a_14540_41600.n109 a_14540_41600.n108 5.38537
R1879 a_14540_41600.n107 a_14540_41600.n106 5.38537
R1880 a_14540_41600.n105 a_14540_41600.n104 5.38537
R1881 a_14540_41600.n1 a_14540_41600.n0 5.32067
R1882 a_14540_41600.n3 a_14540_41600.n2 5.32067
R1883 a_14540_41600.n5 a_14540_41600.n4 5.32067
R1884 a_14540_41600.n7 a_14540_41600.n6 5.32067
R1885 a_14540_41600.n9 a_14540_41600.n8 5.32067
R1886 a_14540_41600.n103 a_14540_41600.n102 4.61063
R1887 a_14540_41600.n79 a_14540_41600.n78 4.42851
R1888 a_14540_41600.n88 a_14540_41600.n87 4.42851
R1889 a_14540_41600.n26 a_14540_41600.n25 4.42851
R1890 a_14540_41600.n47 a_14540_41600.n46 4.42851
R1891 a_14540_41600.n0 a_14540_41600.t13 0.228
R1892 a_14540_41600.n0 a_14540_41600.t16 0.228
R1893 a_14540_41600.n2 a_14540_41600.t7 0.228
R1894 a_14540_41600.n2 a_14540_41600.t14 0.228
R1895 a_14540_41600.n4 a_14540_41600.t5 0.228
R1896 a_14540_41600.n4 a_14540_41600.t8 0.228
R1897 a_14540_41600.n6 a_14540_41600.t18 0.228
R1898 a_14540_41600.n6 a_14540_41600.t6 0.228
R1899 a_14540_41600.n8 a_14540_41600.t11 0.228
R1900 a_14540_41600.n8 a_14540_41600.t19 0.228
R1901 a_14540_41600.n113 a_14540_41600.t9 0.20525
R1902 a_14540_41600.t0 a_14540_41600.n113 0.20525
R1903 a_14540_41600.n110 a_14540_41600.t20 0.20525
R1904 a_14540_41600.n110 a_14540_41600.t10 0.20525
R1905 a_14540_41600.n108 a_14540_41600.t3 0.20525
R1906 a_14540_41600.n108 a_14540_41600.t21 0.20525
R1907 a_14540_41600.n106 a_14540_41600.t22 0.20525
R1908 a_14540_41600.n106 a_14540_41600.t4 0.20525
R1909 a_14540_41600.n104 a_14540_41600.t1 0.20525
R1910 a_14540_41600.n104 a_14540_41600.t23 0.20525
R1911 a_14540_41600.n105 a_14540_41600.n103 0.189974
R1912 a_14540_41600.n107 a_14540_41600.n105 0.189974
R1913 a_14540_41600.n109 a_14540_41600.n107 0.189974
R1914 a_14540_41600.n111 a_14540_41600.n109 0.189974
R1915 a_14540_41600.n112 a_14540_41600.n111 0.189974
R1916 a_14540_41600.n10 a_14540_41600.n9 0.189974
R1917 a_14540_41600.n9 a_14540_41600.n7 0.189974
R1918 a_14540_41600.n7 a_14540_41600.n5 0.189974
R1919 a_14540_41600.n5 a_14540_41600.n3 0.189974
R1920 a_14540_41600.n3 a_14540_41600.n1 0.189974
R1921 a_14540_41600.n95 a_14540_41600.n72 0.1205
R1922 a_14540_41600.n95 a_14540_41600.n94 0.1205
R1923 a_14540_41600.n94 a_14540_41600.n93 0.1205
R1924 a_14540_41600.n93 a_14540_41600.n86 0.1205
R1925 a_14540_41600.n89 a_14540_41600.n86 0.1205
R1926 a_14540_41600.n77 a_14540_41600.n76 0.1205
R1927 a_14540_41600.n76 a_14540_41600.n75 0.1205
R1928 a_14540_41600.n75 a_14540_41600.n74 0.1205
R1929 a_14540_41600.n74 a_14540_41600.n73 0.1205
R1930 a_14540_41600.n99 a_14540_41600.n73 0.1205
R1931 a_14540_41600.n66 a_14540_41600.n11 0.1205
R1932 a_14540_41600.n66 a_14540_41600.n65 0.1205
R1933 a_14540_41600.n65 a_14540_41600.n64 0.1205
R1934 a_14540_41600.n64 a_14540_41600.n41 0.1205
R1935 a_14540_41600.n60 a_14540_41600.n41 0.1205
R1936 a_14540_41600.n60 a_14540_41600.n59 0.1205
R1937 a_14540_41600.n59 a_14540_41600.n58 0.1205
R1938 a_14540_41600.n58 a_14540_41600.n43 0.1205
R1939 a_14540_41600.n54 a_14540_41600.n43 0.1205
R1940 a_14540_41600.n54 a_14540_41600.n53 0.1205
R1941 a_14540_41600.n53 a_14540_41600.n52 0.1205
R1942 a_14540_41600.n52 a_14540_41600.n45 0.1205
R1943 a_14540_41600.n48 a_14540_41600.n45 0.1205
R1944 a_14540_41600.n24 a_14540_41600.n23 0.1205
R1945 a_14540_41600.n23 a_14540_41600.n22 0.1205
R1946 a_14540_41600.n22 a_14540_41600.n21 0.1205
R1947 a_14540_41600.n21 a_14540_41600.n20 0.1205
R1948 a_14540_41600.n20 a_14540_41600.n19 0.1205
R1949 a_14540_41600.n19 a_14540_41600.n18 0.1205
R1950 a_14540_41600.n18 a_14540_41600.n17 0.1205
R1951 a_14540_41600.n17 a_14540_41600.n16 0.1205
R1952 a_14540_41600.n16 a_14540_41600.n15 0.1205
R1953 a_14540_41600.n15 a_14540_41600.n14 0.1205
R1954 a_14540_41600.n14 a_14540_41600.n13 0.1205
R1955 a_14540_41600.n13 a_14540_41600.n12 0.1205
R1956 a_14540_41600.n70 a_14540_41600.n12 0.1205
R1957 a_14540_41600.n100 a_14540_41600.n72 0.0485
R1958 a_14540_41600.n100 a_14540_41600.n99 0.0485
R1959 a_14540_41600.n71 a_14540_41600.n11 0.0485
R1960 a_14540_41600.n71 a_14540_41600.n70 0.0485
R1961 a_6924_41600.n28 a_6924_41600.t19 113.632
R1962 a_6924_41600.n34 a_6924_41600.t8 113.632
R1963 a_6924_41600.n7 a_6924_41600.t31 113.632
R1964 a_6924_41600.n13 a_6924_41600.t20 113.632
R1965 a_6924_41600.n41 a_6924_41600.t13 109.174
R1966 a_6924_41600.n42 a_6924_41600.t14 109.174
R1967 a_6924_41600.n29 a_6924_41600.t18 109.174
R1968 a_6924_41600.n30 a_6924_41600.t17 109.174
R1969 a_6924_41600.n31 a_6924_41600.t16 109.174
R1970 a_6924_41600.n32 a_6924_41600.t15 109.174
R1971 a_6924_41600.n40 a_6924_41600.t12 109.174
R1972 a_6924_41600.n33 a_6924_41600.t11 109.174
R1973 a_6924_41600.n36 a_6924_41600.t10 109.174
R1974 a_6924_41600.n35 a_6924_41600.t9 109.174
R1975 a_6924_41600.n20 a_6924_41600.t25 109.174
R1976 a_6924_41600.n21 a_6924_41600.t26 109.174
R1977 a_6924_41600.n8 a_6924_41600.t30 109.174
R1978 a_6924_41600.n9 a_6924_41600.t29 109.174
R1979 a_6924_41600.n10 a_6924_41600.t28 109.174
R1980 a_6924_41600.n11 a_6924_41600.t27 109.174
R1981 a_6924_41600.n19 a_6924_41600.t24 109.174
R1982 a_6924_41600.n12 a_6924_41600.t23 109.174
R1983 a_6924_41600.n15 a_6924_41600.t22 109.174
R1984 a_6924_41600.n14 a_6924_41600.t21 109.174
R1985 a_6924_41600.n41 a_6924_41600.n24 18.4942
R1986 a_6924_41600.n43 a_6924_41600.n42 18.4942
R1987 a_6924_41600.n30 a_6924_41600.n27 18.4942
R1988 a_6924_41600.n31 a_6924_41600.n26 18.4942
R1989 a_6924_41600.n32 a_6924_41600.n25 18.4942
R1990 a_6924_41600.n40 a_6924_41600.n39 18.4942
R1991 a_6924_41600.n38 a_6924_41600.n33 18.4942
R1992 a_6924_41600.n37 a_6924_41600.n36 18.4942
R1993 a_6924_41600.n20 a_6924_41600.n3 18.4942
R1994 a_6924_41600.n22 a_6924_41600.n21 18.4942
R1995 a_6924_41600.n9 a_6924_41600.n6 18.4942
R1996 a_6924_41600.n10 a_6924_41600.n5 18.4942
R1997 a_6924_41600.n11 a_6924_41600.n4 18.4942
R1998 a_6924_41600.n19 a_6924_41600.n18 18.4942
R1999 a_6924_41600.n17 a_6924_41600.n12 18.4942
R2000 a_6924_41600.n16 a_6924_41600.n15 18.4942
R2001 a_6924_41600.n46 a_6924_41600.n45 17.906
R2002 a_6924_41600.n41 a_6924_41600.n40 11.6805
R2003 a_6924_41600.n42 a_6924_41600.n41 11.6805
R2004 a_6924_41600.n30 a_6924_41600.n29 11.6805
R2005 a_6924_41600.n31 a_6924_41600.n30 11.6805
R2006 a_6924_41600.n32 a_6924_41600.n31 11.6805
R2007 a_6924_41600.n42 a_6924_41600.n32 11.6805
R2008 a_6924_41600.n40 a_6924_41600.n33 11.6805
R2009 a_6924_41600.n36 a_6924_41600.n33 11.6805
R2010 a_6924_41600.n36 a_6924_41600.n35 11.6805
R2011 a_6924_41600.n20 a_6924_41600.n19 11.6805
R2012 a_6924_41600.n21 a_6924_41600.n20 11.6805
R2013 a_6924_41600.n9 a_6924_41600.n8 11.6805
R2014 a_6924_41600.n10 a_6924_41600.n9 11.6805
R2015 a_6924_41600.n11 a_6924_41600.n10 11.6805
R2016 a_6924_41600.n21 a_6924_41600.n11 11.6805
R2017 a_6924_41600.n19 a_6924_41600.n12 11.6805
R2018 a_6924_41600.n15 a_6924_41600.n12 11.6805
R2019 a_6924_41600.n15 a_6924_41600.n14 11.6805
R2020 a_6924_41600.n45 a_6924_41600.n23 10.013
R2021 a_6924_41600.n45 a_6924_41600.n44 9.91657
R2022 a_6924_41600.n37 a_6924_41600.n34 7.17687
R2023 a_6924_41600.n28 a_6924_41600.n27 7.17687
R2024 a_6924_41600.n16 a_6924_41600.n13 7.17687
R2025 a_6924_41600.n7 a_6924_41600.n6 7.17687
R2026 a_6924_41600.n46 a_6924_41600.n2 6.5392
R2027 a_6924_41600.t3 a_6924_41600.n49 5.7796
R2028 a_6924_41600.n1 a_6924_41600.t7 5.73764
R2029 a_6924_41600.n47 a_6924_41600.t0 5.59012
R2030 a_6924_41600.n2 a_6924_41600.t4 5.54817
R2031 a_6924_41600.n49 a_6924_41600.n48 5.38537
R2032 a_6924_41600.n1 a_6924_41600.n0 5.32067
R2033 a_6924_41600.n47 a_6924_41600.n46 4.61063
R2034 a_6924_41600.n29 a_6924_41600.n28 4.42851
R2035 a_6924_41600.n35 a_6924_41600.n34 4.42851
R2036 a_6924_41600.n8 a_6924_41600.n7 4.42851
R2037 a_6924_41600.n14 a_6924_41600.n13 4.42851
R2038 a_6924_41600.n0 a_6924_41600.t5 0.228
R2039 a_6924_41600.n0 a_6924_41600.t6 0.228
R2040 a_6924_41600.n48 a_6924_41600.t1 0.20525
R2041 a_6924_41600.n48 a_6924_41600.t2 0.20525
R2042 a_6924_41600.n49 a_6924_41600.n47 0.189974
R2043 a_6924_41600.n2 a_6924_41600.n1 0.189974
R2044 a_6924_41600.n39 a_6924_41600.n24 0.1205
R2045 a_6924_41600.n39 a_6924_41600.n38 0.1205
R2046 a_6924_41600.n38 a_6924_41600.n37 0.1205
R2047 a_6924_41600.n27 a_6924_41600.n26 0.1205
R2048 a_6924_41600.n26 a_6924_41600.n25 0.1205
R2049 a_6924_41600.n43 a_6924_41600.n25 0.1205
R2050 a_6924_41600.n18 a_6924_41600.n3 0.1205
R2051 a_6924_41600.n18 a_6924_41600.n17 0.1205
R2052 a_6924_41600.n17 a_6924_41600.n16 0.1205
R2053 a_6924_41600.n6 a_6924_41600.n5 0.1205
R2054 a_6924_41600.n5 a_6924_41600.n4 0.1205
R2055 a_6924_41600.n22 a_6924_41600.n4 0.1205
R2056 a_6924_41600.n44 a_6924_41600.n24 0.0485
R2057 a_6924_41600.n44 a_6924_41600.n43 0.0485
R2058 a_6924_41600.n23 a_6924_41600.n3 0.0485
R2059 a_6924_41600.n23 a_6924_41600.n22 0.0485
R2060 a_4812_41600.n18 a_4812_41600.t15 113.632
R2061 a_4812_41600.n22 a_4812_41600.t8 113.632
R2062 a_4812_41600.n5 a_4812_41600.t23 113.632
R2063 a_4812_41600.n9 a_4812_41600.t16 113.632
R2064 a_4812_41600.n25 a_4812_41600.t11 109.174
R2065 a_4812_41600.n26 a_4812_41600.t12 109.174
R2066 a_4812_41600.n19 a_4812_41600.t14 109.174
R2067 a_4812_41600.n20 a_4812_41600.t13 109.174
R2068 a_4812_41600.n24 a_4812_41600.t10 109.174
R2069 a_4812_41600.n21 a_4812_41600.t9 109.174
R2070 a_4812_41600.n12 a_4812_41600.t19 109.174
R2071 a_4812_41600.n13 a_4812_41600.t20 109.174
R2072 a_4812_41600.n6 a_4812_41600.t22 109.174
R2073 a_4812_41600.n7 a_4812_41600.t21 109.174
R2074 a_4812_41600.n11 a_4812_41600.t18 109.174
R2075 a_4812_41600.n8 a_4812_41600.t17 109.174
R2076 a_4812_41600.n25 a_4812_41600.n16 18.4942
R2077 a_4812_41600.n27 a_4812_41600.n26 18.4942
R2078 a_4812_41600.n20 a_4812_41600.n17 18.4942
R2079 a_4812_41600.n24 a_4812_41600.n23 18.4942
R2080 a_4812_41600.n12 a_4812_41600.n3 18.4942
R2081 a_4812_41600.n14 a_4812_41600.n13 18.4942
R2082 a_4812_41600.n7 a_4812_41600.n4 18.4942
R2083 a_4812_41600.n11 a_4812_41600.n10 18.4942
R2084 a_4812_41600.n30 a_4812_41600.n29 17.3044
R2085 a_4812_41600.n25 a_4812_41600.n24 11.6805
R2086 a_4812_41600.n26 a_4812_41600.n25 11.6805
R2087 a_4812_41600.n20 a_4812_41600.n19 11.6805
R2088 a_4812_41600.n26 a_4812_41600.n20 11.6805
R2089 a_4812_41600.n24 a_4812_41600.n21 11.6805
R2090 a_4812_41600.n12 a_4812_41600.n11 11.6805
R2091 a_4812_41600.n13 a_4812_41600.n12 11.6805
R2092 a_4812_41600.n7 a_4812_41600.n6 11.6805
R2093 a_4812_41600.n13 a_4812_41600.n7 11.6805
R2094 a_4812_41600.n11 a_4812_41600.n8 11.6805
R2095 a_4812_41600.n29 a_4812_41600.n15 10.3505
R2096 a_4812_41600.n29 a_4812_41600.n28 9.57907
R2097 a_4812_41600.n23 a_4812_41600.n22 7.17687
R2098 a_4812_41600.n18 a_4812_41600.n17 7.17687
R2099 a_4812_41600.n10 a_4812_41600.n9 7.17687
R2100 a_4812_41600.n5 a_4812_41600.n4 7.17687
R2101 a_4812_41600.n30 a_4812_41600.n2 6.5392
R2102 a_4812_41600.t3 a_4812_41600.n33 5.7796
R2103 a_4812_41600.n1 a_4812_41600.t7 5.73764
R2104 a_4812_41600.n31 a_4812_41600.t0 5.59012
R2105 a_4812_41600.n2 a_4812_41600.t4 5.54817
R2106 a_4812_41600.n33 a_4812_41600.n32 5.38537
R2107 a_4812_41600.n1 a_4812_41600.n0 5.32067
R2108 a_4812_41600.n31 a_4812_41600.n30 4.61063
R2109 a_4812_41600.n19 a_4812_41600.n18 4.42851
R2110 a_4812_41600.n22 a_4812_41600.n21 4.42851
R2111 a_4812_41600.n6 a_4812_41600.n5 4.42851
R2112 a_4812_41600.n9 a_4812_41600.n8 4.42851
R2113 a_4812_41600.n0 a_4812_41600.t5 0.228
R2114 a_4812_41600.n0 a_4812_41600.t6 0.228
R2115 a_4812_41600.n32 a_4812_41600.t1 0.20525
R2116 a_4812_41600.n32 a_4812_41600.t2 0.20525
R2117 a_4812_41600.n33 a_4812_41600.n31 0.189974
R2118 a_4812_41600.n2 a_4812_41600.n1 0.189974
R2119 a_4812_41600.n23 a_4812_41600.n16 0.1205
R2120 a_4812_41600.n27 a_4812_41600.n17 0.1205
R2121 a_4812_41600.n10 a_4812_41600.n3 0.1205
R2122 a_4812_41600.n14 a_4812_41600.n4 0.1205
R2123 a_4812_41600.n28 a_4812_41600.n16 0.0485
R2124 a_4812_41600.n28 a_4812_41600.n27 0.0485
R2125 a_4812_41600.n15 a_4812_41600.n3 0.0485
R2126 a_4812_41600.n15 a_4812_41600.n14 0.0485
R2127 a_2700_41600.n18 a_2700_41600.t15 113.632
R2128 a_2700_41600.n22 a_2700_41600.t8 113.632
R2129 a_2700_41600.n5 a_2700_41600.t23 113.632
R2130 a_2700_41600.n9 a_2700_41600.t16 113.632
R2131 a_2700_41600.n25 a_2700_41600.t11 109.174
R2132 a_2700_41600.n26 a_2700_41600.t12 109.174
R2133 a_2700_41600.n19 a_2700_41600.t14 109.174
R2134 a_2700_41600.n20 a_2700_41600.t13 109.174
R2135 a_2700_41600.n24 a_2700_41600.t10 109.174
R2136 a_2700_41600.n21 a_2700_41600.t9 109.174
R2137 a_2700_41600.n12 a_2700_41600.t19 109.174
R2138 a_2700_41600.n13 a_2700_41600.t20 109.174
R2139 a_2700_41600.n6 a_2700_41600.t22 109.174
R2140 a_2700_41600.n7 a_2700_41600.t21 109.174
R2141 a_2700_41600.n11 a_2700_41600.t18 109.174
R2142 a_2700_41600.n8 a_2700_41600.t17 109.174
R2143 a_2700_41600.n25 a_2700_41600.n16 18.4942
R2144 a_2700_41600.n27 a_2700_41600.n26 18.4942
R2145 a_2700_41600.n20 a_2700_41600.n17 18.4942
R2146 a_2700_41600.n24 a_2700_41600.n23 18.4942
R2147 a_2700_41600.n12 a_2700_41600.n3 18.4942
R2148 a_2700_41600.n14 a_2700_41600.n13 18.4942
R2149 a_2700_41600.n7 a_2700_41600.n4 18.4942
R2150 a_2700_41600.n11 a_2700_41600.n10 18.4942
R2151 a_2700_41600.n30 a_2700_41600.n29 17.0158
R2152 a_2700_41600.n25 a_2700_41600.n24 11.6805
R2153 a_2700_41600.n26 a_2700_41600.n25 11.6805
R2154 a_2700_41600.n20 a_2700_41600.n19 11.6805
R2155 a_2700_41600.n26 a_2700_41600.n20 11.6805
R2156 a_2700_41600.n24 a_2700_41600.n21 11.6805
R2157 a_2700_41600.n12 a_2700_41600.n11 11.6805
R2158 a_2700_41600.n13 a_2700_41600.n12 11.6805
R2159 a_2700_41600.n7 a_2700_41600.n6 11.6805
R2160 a_2700_41600.n13 a_2700_41600.n7 11.6805
R2161 a_2700_41600.n11 a_2700_41600.n8 11.6805
R2162 a_2700_41600.n29 a_2700_41600.n15 10.688
R2163 a_2700_41600.n29 a_2700_41600.n28 9.24157
R2164 a_2700_41600.n23 a_2700_41600.n22 7.17687
R2165 a_2700_41600.n18 a_2700_41600.n17 7.17687
R2166 a_2700_41600.n10 a_2700_41600.n9 7.17687
R2167 a_2700_41600.n5 a_2700_41600.n4 7.17687
R2168 a_2700_41600.n30 a_2700_41600.n2 6.5392
R2169 a_2700_41600.t3 a_2700_41600.n33 5.7796
R2170 a_2700_41600.n1 a_2700_41600.t7 5.73764
R2171 a_2700_41600.n31 a_2700_41600.t0 5.59012
R2172 a_2700_41600.n2 a_2700_41600.t4 5.54817
R2173 a_2700_41600.n33 a_2700_41600.n32 5.38537
R2174 a_2700_41600.n1 a_2700_41600.n0 5.32067
R2175 a_2700_41600.n31 a_2700_41600.n30 4.61063
R2176 a_2700_41600.n19 a_2700_41600.n18 4.42851
R2177 a_2700_41600.n22 a_2700_41600.n21 4.42851
R2178 a_2700_41600.n6 a_2700_41600.n5 4.42851
R2179 a_2700_41600.n9 a_2700_41600.n8 4.42851
R2180 a_2700_41600.n0 a_2700_41600.t5 0.228
R2181 a_2700_41600.n0 a_2700_41600.t6 0.228
R2182 a_2700_41600.n32 a_2700_41600.t1 0.20525
R2183 a_2700_41600.n32 a_2700_41600.t2 0.20525
R2184 a_2700_41600.n33 a_2700_41600.n31 0.189974
R2185 a_2700_41600.n2 a_2700_41600.n1 0.189974
R2186 a_2700_41600.n23 a_2700_41600.n16 0.1205
R2187 a_2700_41600.n27 a_2700_41600.n17 0.1205
R2188 a_2700_41600.n10 a_2700_41600.n3 0.1205
R2189 a_2700_41600.n14 a_2700_41600.n4 0.1205
R2190 a_2700_41600.n28 a_2700_41600.n16 0.0485
R2191 a_2700_41600.n28 a_2700_41600.n27 0.0485
R2192 a_2700_41600.n15 a_2700_41600.n3 0.0485
R2193 a_2700_41600.n15 a_2700_41600.n14 0.0485
C0 CLKP_HB VDD 3.08923f
C1 E_CAPTURE_CLKB E_CAPTURE_CLK 0.13895f
C2 CLKP_H VDD 2.93876f
C3 CLKN_HB O_CAPTURE_CLKB 0.04486f
C4 CLKN_H VDD 2.93876f
C5 O_CAPTURE_CLK VDD 11.2501f
C6 E_CAPTURE_CLKB CLKP_HB 0.04486f
C7 O_SENSE VDD 40.8703f
C8 E_SENSE VDD 40.8703f
C9 E_CAPTURE_CLK VDD 11.2501f
C10 CLKN_HB CLKN_H 0.13381f
C11 E_CAPTURE_CLKB VDD 11.3084f
C12 CLKN_HB VDD 3.08923f
C13 CLKP_H CLKP_HB 0.13381f
C14 O_CAPTURE_CLK O_CAPTURE_CLKB 0.13895f
C15 O_CAPTURE_CLKB VDD 11.3084f
C16 E_SENSE VSS 26.36908f
C17 E_CAPTURE_CLK VSS 13.22105f
C18 E_CAPTURE_CLKB VSS 11.51597f
C19 CLKP_H VSS 8.92236f
C20 CLKP_HB VSS 10.42647f
C21 O_SENSE VSS 26.36908f
C22 O_CAPTURE_CLK VSS 13.22105f
C23 O_CAPTURE_CLKB VSS 11.51597f
C24 CLKN_H VSS 8.92236f
C25 CLKN_HB VSS 10.89566f
C26 VDD VSS 2.46155p
C27 a_2700_41600.t7 VSS 0.78846f
C28 a_2700_41600.t6 VSS 0.18273f
C29 a_2700_41600.t5 VSS 0.18273f
C30 a_2700_41600.n0 VSS 0.58157f
C31 a_2700_41600.n1 VSS 0.31967f
C32 a_2700_41600.t4 VSS 0.78324f
C33 a_2700_41600.n2 VSS 0.34526f
C34 a_2700_41600.n3 VSS 0.05376f
C35 a_2700_41600.n4 VSS 0.18572f
C36 a_2700_41600.n5 VSS 0.0918f
C37 a_2700_41600.n6 VSS 0.0984f
C38 a_2700_41600.n7 VSS 0.0984f
C39 a_2700_41600.n8 VSS 0.0984f
C40 a_2700_41600.n9 VSS 0.0918f
C41 a_2700_41600.n10 VSS 0.18572f
C42 a_2700_41600.n11 VSS 0.0984f
C43 a_2700_41600.n12 VSS 0.0984f
C44 a_2700_41600.n13 VSS 0.0984f
C45 a_2700_41600.n14 VSS 0.05376f
C46 a_2700_41600.n15 VSS 0.30181f
C47 a_2700_41600.n16 VSS 0.05376f
C48 a_2700_41600.n17 VSS 0.18572f
C49 a_2700_41600.n18 VSS 0.0918f
C50 a_2700_41600.n19 VSS 0.0984f
C51 a_2700_41600.n20 VSS 0.0984f
C52 a_2700_41600.n21 VSS 0.0984f
C53 a_2700_41600.n22 VSS 0.0918f
C54 a_2700_41600.n23 VSS 0.18572f
C55 a_2700_41600.n24 VSS 0.0984f
C56 a_2700_41600.n25 VSS 0.0984f
C57 a_2700_41600.n26 VSS 0.0984f
C58 a_2700_41600.n27 VSS 0.05376f
C59 a_2700_41600.n28 VSS 0.22605f
C60 a_2700_41600.n29 VSS 2.02655f
C61 a_2700_41600.n30 VSS 1.88452f
C62 a_2700_41600.t0 VSS 0.78185f
C63 a_2700_41600.n31 VSS 0.23411f
C64 a_2700_41600.t2 VSS 0.18273f
C65 a_2700_41600.t1 VSS 0.18273f
C66 a_2700_41600.n32 VSS 0.57729f
C67 a_2700_41600.n33 VSS 0.32535f
C68 a_2700_41600.t3 VSS 0.78707f
C69 a_4812_41600.t7 VSS 0.81128f
C70 a_4812_41600.t6 VSS 0.18016f
C71 a_4812_41600.t5 VSS 0.18016f
C72 a_4812_41600.n0 VSS 0.60614f
C73 a_4812_41600.n1 VSS 0.33317f
C74 a_4812_41600.t4 VSS 0.80584f
C75 a_4812_41600.n2 VSS 0.35985f
C76 a_4812_41600.n3 VSS 0.05603f
C77 a_4812_41600.n4 VSS 0.19357f
C78 a_4812_41600.n5 VSS 0.09568f
C79 a_4812_41600.n6 VSS 0.10256f
C80 a_4812_41600.n7 VSS 0.10256f
C81 a_4812_41600.n8 VSS 0.10256f
C82 a_4812_41600.n9 VSS 0.09568f
C83 a_4812_41600.n10 VSS 0.19357f
C84 a_4812_41600.n11 VSS 0.10256f
C85 a_4812_41600.n12 VSS 0.10256f
C86 a_4812_41600.n13 VSS 0.10256f
C87 a_4812_41600.n14 VSS 0.05603f
C88 a_4812_41600.n15 VSS 0.29102f
C89 a_4812_41600.n16 VSS 0.05603f
C90 a_4812_41600.n17 VSS 0.19357f
C91 a_4812_41600.n18 VSS 0.09568f
C92 a_4812_41600.n19 VSS 0.10256f
C93 a_4812_41600.n20 VSS 0.10256f
C94 a_4812_41600.n21 VSS 0.10256f
C95 a_4812_41600.n22 VSS 0.09568f
C96 a_4812_41600.n23 VSS 0.19357f
C97 a_4812_41600.n24 VSS 0.10256f
C98 a_4812_41600.n25 VSS 0.10256f
C99 a_4812_41600.n26 VSS 0.10256f
C100 a_4812_41600.n27 VSS 0.05603f
C101 a_4812_41600.n28 VSS 0.24849f
C102 a_4812_41600.n29 VSS 2.18227f
C103 a_4812_41600.n30 VSS 1.93796f
C104 a_4812_41600.t0 VSS 0.80438f
C105 a_4812_41600.n31 VSS 0.244f
C106 a_4812_41600.t2 VSS 0.18016f
C107 a_4812_41600.t1 VSS 0.18016f
C108 a_4812_41600.n32 VSS 0.60167f
C109 a_4812_41600.n33 VSS 0.33909f
C110 a_4812_41600.t3 VSS 0.80983f
C111 a_6924_41600.t7 VSS 0.76845f
C112 a_6924_41600.t6 VSS 0.17959f
C113 a_6924_41600.t5 VSS 0.17959f
C114 a_6924_41600.n0 VSS 0.56534f
C115 a_6924_41600.n1 VSS 0.31075f
C116 a_6924_41600.t4 VSS 0.76338f
C117 a_6924_41600.n2 VSS 0.33562f
C118 a_6924_41600.n3 VSS 0.05226f
C119 a_6924_41600.n4 VSS 0.06203f
C120 a_6924_41600.n5 VSS 0.06203f
C121 a_6924_41600.n6 VSS 0.18054f
C122 a_6924_41600.n7 VSS 0.08924f
C123 a_6924_41600.n8 VSS 0.09565f
C124 a_6924_41600.n9 VSS 0.09565f
C125 a_6924_41600.n10 VSS 0.09565f
C126 a_6924_41600.n11 VSS 0.09565f
C127 a_6924_41600.n12 VSS 0.09565f
C128 a_6924_41600.n13 VSS 0.08924f
C129 a_6924_41600.n14 VSS 0.09565f
C130 a_6924_41600.n15 VSS 0.09565f
C131 a_6924_41600.n16 VSS 0.18054f
C132 a_6924_41600.n17 VSS 0.06203f
C133 a_6924_41600.n18 VSS 0.06203f
C134 a_6924_41600.n19 VSS 0.09565f
C135 a_6924_41600.n20 VSS 0.09565f
C136 a_6924_41600.n21 VSS 0.09565f
C137 a_6924_41600.n22 VSS 0.05226f
C138 a_6924_41600.n23 VSS 0.35576f
C139 a_6924_41600.n24 VSS 0.05226f
C140 a_6924_41600.n25 VSS 0.06203f
C141 a_6924_41600.n26 VSS 0.06203f
C142 a_6924_41600.n27 VSS 0.18054f
C143 a_6924_41600.n28 VSS 0.08924f
C144 a_6924_41600.n29 VSS 0.09565f
C145 a_6924_41600.n30 VSS 0.09565f
C146 a_6924_41600.n31 VSS 0.09565f
C147 a_6924_41600.n32 VSS 0.09565f
C148 a_6924_41600.n33 VSS 0.09565f
C149 a_6924_41600.n34 VSS 0.08924f
C150 a_6924_41600.n35 VSS 0.09565f
C151 a_6924_41600.n36 VSS 0.09565f
C152 a_6924_41600.n37 VSS 0.18054f
C153 a_6924_41600.n38 VSS 0.06203f
C154 a_6924_41600.n39 VSS 0.06203f
C155 a_6924_41600.n40 VSS 0.09565f
C156 a_6924_41600.n41 VSS 0.09565f
C157 a_6924_41600.n42 VSS 0.09565f
C158 a_6924_41600.n43 VSS 0.05226f
C159 a_6924_41600.n44 VSS 0.34996f
C160 a_6924_41600.n45 VSS 2.30382f
C161 a_6924_41600.n46 VSS 1.82128f
C162 a_6924_41600.t0 VSS 0.76202f
C163 a_6924_41600.n47 VSS 0.22757f
C164 a_6924_41600.t2 VSS 0.17959f
C165 a_6924_41600.t1 VSS 0.17959f
C166 a_6924_41600.n48 VSS 0.56117f
C167 a_6924_41600.n49 VSS 0.31627f
C168 a_6924_41600.t3 VSS 0.7671f
C169 a_14540_41600.t9 VSS 0.21265f
C170 a_14540_41600.t17 VSS 0.85744f
C171 a_14540_41600.t15 VSS 0.85893f
C172 a_14540_41600.t16 VSS 0.21265f
C173 a_14540_41600.t13 VSS 0.21265f
C174 a_14540_41600.n0 VSS 0.62017f
C175 a_14540_41600.n1 VSS 0.34089f
C176 a_14540_41600.t14 VSS 0.21265f
C177 a_14540_41600.t7 VSS 0.21265f
C178 a_14540_41600.n2 VSS 0.62017f
C179 a_14540_41600.n3 VSS 0.17795f
C180 a_14540_41600.t8 VSS 0.21265f
C181 a_14540_41600.t5 VSS 0.21265f
C182 a_14540_41600.n4 VSS 0.62017f
C183 a_14540_41600.n5 VSS 0.17795f
C184 a_14540_41600.t6 VSS 0.21265f
C185 a_14540_41600.t18 VSS 0.21265f
C186 a_14540_41600.n6 VSS 0.62017f
C187 a_14540_41600.n7 VSS 0.17795f
C188 a_14540_41600.t19 VSS 0.21265f
C189 a_14540_41600.t11 VSS 0.21265f
C190 a_14540_41600.n8 VSS 0.62017f
C191 a_14540_41600.n9 VSS 0.17795f
C192 a_14540_41600.t12 VSS 0.85336f
C193 a_14540_41600.n10 VSS 0.36817f
C194 a_14540_41600.n11 VSS 0.05733f
C195 a_14540_41600.n12 VSS 0.06804f
C196 a_14540_41600.n13 VSS 0.06804f
C197 a_14540_41600.n14 VSS 0.06804f
C198 a_14540_41600.n15 VSS 0.06804f
C199 a_14540_41600.n16 VSS 0.06804f
C200 a_14540_41600.n17 VSS 0.06804f
C201 a_14540_41600.n18 VSS 0.06804f
C202 a_14540_41600.n19 VSS 0.06804f
C203 a_14540_41600.n20 VSS 0.06804f
C204 a_14540_41600.n21 VSS 0.06804f
C205 a_14540_41600.n22 VSS 0.06804f
C206 a_14540_41600.n23 VSS 0.06804f
C207 a_14540_41600.n24 VSS 0.19805f
C208 a_14540_41600.n25 VSS 0.09789f
C209 a_14540_41600.n26 VSS 0.10493f
C210 a_14540_41600.n27 VSS 0.10493f
C211 a_14540_41600.n28 VSS 0.10493f
C212 a_14540_41600.n29 VSS 0.10493f
C213 a_14540_41600.n30 VSS 0.10493f
C214 a_14540_41600.n31 VSS 0.10493f
C215 a_14540_41600.n32 VSS 0.10493f
C216 a_14540_41600.n33 VSS 0.10493f
C217 a_14540_41600.n34 VSS 0.10493f
C218 a_14540_41600.n35 VSS 0.10493f
C219 a_14540_41600.n36 VSS 0.10493f
C220 a_14540_41600.n37 VSS 0.10493f
C221 a_14540_41600.n38 VSS 0.10493f
C222 a_14540_41600.n39 VSS 0.10493f
C223 a_14540_41600.n40 VSS 0.10493f
C224 a_14540_41600.n41 VSS 0.06804f
C225 a_14540_41600.n42 VSS 0.10493f
C226 a_14540_41600.n43 VSS 0.06804f
C227 a_14540_41600.n44 VSS 0.10493f
C228 a_14540_41600.n45 VSS 0.06804f
C229 a_14540_41600.n46 VSS 0.10493f
C230 a_14540_41600.n47 VSS 0.09789f
C231 a_14540_41600.n48 VSS 0.19805f
C232 a_14540_41600.n49 VSS 0.10493f
C233 a_14540_41600.n50 VSS 0.10493f
C234 a_14540_41600.n51 VSS 0.10493f
C235 a_14540_41600.n52 VSS 0.06804f
C236 a_14540_41600.n53 VSS 0.06804f
C237 a_14540_41600.n54 VSS 0.06804f
C238 a_14540_41600.n55 VSS 0.10493f
C239 a_14540_41600.n56 VSS 0.10493f
C240 a_14540_41600.n57 VSS 0.10493f
C241 a_14540_41600.n58 VSS 0.06804f
C242 a_14540_41600.n59 VSS 0.06804f
C243 a_14540_41600.n60 VSS 0.06804f
C244 a_14540_41600.n61 VSS 0.10493f
C245 a_14540_41600.n62 VSS 0.10493f
C246 a_14540_41600.n63 VSS 0.10493f
C247 a_14540_41600.n64 VSS 0.06804f
C248 a_14540_41600.n65 VSS 0.06804f
C249 a_14540_41600.n66 VSS 0.06804f
C250 a_14540_41600.n67 VSS 0.10493f
C251 a_14540_41600.n68 VSS 0.10493f
C252 a_14540_41600.n69 VSS 0.10493f
C253 a_14540_41600.n70 VSS 0.05733f
C254 a_14540_41600.n71 VSS 1.03896f
C255 a_14540_41600.n72 VSS 0.05733f
C256 a_14540_41600.n73 VSS 0.06804f
C257 a_14540_41600.n74 VSS 0.06804f
C258 a_14540_41600.n75 VSS 0.06804f
C259 a_14540_41600.n76 VSS 0.06804f
C260 a_14540_41600.n77 VSS 0.19805f
C261 a_14540_41600.n78 VSS 0.09789f
C262 a_14540_41600.n79 VSS 0.10493f
C263 a_14540_41600.n80 VSS 0.10493f
C264 a_14540_41600.n81 VSS 0.10493f
C265 a_14540_41600.n82 VSS 0.10493f
C266 a_14540_41600.n83 VSS 0.10493f
C267 a_14540_41600.n84 VSS 0.10493f
C268 a_14540_41600.n85 VSS 0.10493f
C269 a_14540_41600.n86 VSS 0.06804f
C270 a_14540_41600.n87 VSS 0.10493f
C271 a_14540_41600.n88 VSS 0.09789f
C272 a_14540_41600.n89 VSS 0.19805f
C273 a_14540_41600.n90 VSS 0.10493f
C274 a_14540_41600.n91 VSS 0.10493f
C275 a_14540_41600.n92 VSS 0.10493f
C276 a_14540_41600.n93 VSS 0.06804f
C277 a_14540_41600.n94 VSS 0.06804f
C278 a_14540_41600.n95 VSS 0.06804f
C279 a_14540_41600.n96 VSS 0.10493f
C280 a_14540_41600.n97 VSS 0.10493f
C281 a_14540_41600.n98 VSS 0.10493f
C282 a_14540_41600.n99 VSS 0.05733f
C283 a_14540_41600.n100 VSS 0.45288f
C284 a_14540_41600.n101 VSS 2.74379f
C285 a_14540_41600.n102 VSS 1.8781f
C286 a_14540_41600.t2 VSS 0.85187f
C287 a_14540_41600.n103 VSS 0.24965f
C288 a_14540_41600.t23 VSS 0.21265f
C289 a_14540_41600.t1 VSS 0.21265f
C290 a_14540_41600.n104 VSS 0.6156f
C291 a_14540_41600.n105 VSS 0.18252f
C292 a_14540_41600.t4 VSS 0.21265f
C293 a_14540_41600.t22 VSS 0.21265f
C294 a_14540_41600.n106 VSS 0.6156f
C295 a_14540_41600.n107 VSS 0.18252f
C296 a_14540_41600.t21 VSS 0.21265f
C297 a_14540_41600.t3 VSS 0.21265f
C298 a_14540_41600.n108 VSS 0.6156f
C299 a_14540_41600.n109 VSS 0.18252f
C300 a_14540_41600.t10 VSS 0.21265f
C301 a_14540_41600.t20 VSS 0.21265f
C302 a_14540_41600.n110 VSS 0.6156f
C303 a_14540_41600.n111 VSS 0.18252f
C304 a_14540_41600.n112 VSS 0.34694f
C305 a_14540_41600.n113 VSS 0.6156f
C306 a_14540_41600.t0 VSS 0.21265f
C307 a_2700_6400.t7 VSS 0.78987f
C308 a_2700_6400.t6 VSS 0.18411f
C309 a_2700_6400.t5 VSS 0.18411f
C310 a_2700_6400.n0 VSS 0.58157f
C311 a_2700_6400.n1 VSS 0.31967f
C312 a_2700_6400.t4 VSS 0.78465f
C313 a_2700_6400.n2 VSS 0.34526f
C314 a_2700_6400.n3 VSS 0.05376f
C315 a_2700_6400.n4 VSS 0.18572f
C316 a_2700_6400.n5 VSS 0.0918f
C317 a_2700_6400.n6 VSS 0.0984f
C318 a_2700_6400.n7 VSS 0.0984f
C319 a_2700_6400.n8 VSS 0.0984f
C320 a_2700_6400.n9 VSS 0.0918f
C321 a_2700_6400.n10 VSS 0.18572f
C322 a_2700_6400.n11 VSS 0.0984f
C323 a_2700_6400.n12 VSS 0.0984f
C324 a_2700_6400.n13 VSS 0.0984f
C325 a_2700_6400.n14 VSS 0.05376f
C326 a_2700_6400.n15 VSS 0.30181f
C327 a_2700_6400.n16 VSS 0.05376f
C328 a_2700_6400.n17 VSS 0.18572f
C329 a_2700_6400.n18 VSS 0.0918f
C330 a_2700_6400.n19 VSS 0.0984f
C331 a_2700_6400.n20 VSS 0.0984f
C332 a_2700_6400.n21 VSS 0.0984f
C333 a_2700_6400.n22 VSS 0.0918f
C334 a_2700_6400.n23 VSS 0.18572f
C335 a_2700_6400.n24 VSS 0.0984f
C336 a_2700_6400.n25 VSS 0.0984f
C337 a_2700_6400.n26 VSS 0.0984f
C338 a_2700_6400.n27 VSS 0.05376f
C339 a_2700_6400.n28 VSS 0.22605f
C340 a_2700_6400.n29 VSS 2.02655f
C341 a_2700_6400.n30 VSS 1.88452f
C342 a_2700_6400.t0 VSS 0.78326f
C343 a_2700_6400.n31 VSS 0.23411f
C344 a_2700_6400.t2 VSS 0.18411f
C345 a_2700_6400.t1 VSS 0.18411f
C346 a_2700_6400.n32 VSS 0.57729f
C347 a_2700_6400.n33 VSS 0.32535f
C348 a_2700_6400.t3 VSS 0.78848f
C349 a_4812_6400.t7 VSS 0.81128f
C350 a_4812_6400.t6 VSS 0.18016f
C351 a_4812_6400.t5 VSS 0.18016f
C352 a_4812_6400.n0 VSS 0.60614f
C353 a_4812_6400.n1 VSS 0.33317f
C354 a_4812_6400.t4 VSS 0.80584f
C355 a_4812_6400.n2 VSS 0.35985f
C356 a_4812_6400.n3 VSS 0.05603f
C357 a_4812_6400.n4 VSS 0.19357f
C358 a_4812_6400.n5 VSS 0.09568f
C359 a_4812_6400.n6 VSS 0.10256f
C360 a_4812_6400.n7 VSS 0.10256f
C361 a_4812_6400.n8 VSS 0.10256f
C362 a_4812_6400.n9 VSS 0.09568f
C363 a_4812_6400.n10 VSS 0.19357f
C364 a_4812_6400.n11 VSS 0.10256f
C365 a_4812_6400.n12 VSS 0.10256f
C366 a_4812_6400.n13 VSS 0.10256f
C367 a_4812_6400.n14 VSS 0.05603f
C368 a_4812_6400.n15 VSS 0.29102f
C369 a_4812_6400.n16 VSS 0.05603f
C370 a_4812_6400.n17 VSS 0.19357f
C371 a_4812_6400.n18 VSS 0.09568f
C372 a_4812_6400.n19 VSS 0.10256f
C373 a_4812_6400.n20 VSS 0.10256f
C374 a_4812_6400.n21 VSS 0.10256f
C375 a_4812_6400.n22 VSS 0.09568f
C376 a_4812_6400.n23 VSS 0.19357f
C377 a_4812_6400.n24 VSS 0.10256f
C378 a_4812_6400.n25 VSS 0.10256f
C379 a_4812_6400.n26 VSS 0.10256f
C380 a_4812_6400.n27 VSS 0.05603f
C381 a_4812_6400.n28 VSS 0.24849f
C382 a_4812_6400.n29 VSS 2.18227f
C383 a_4812_6400.n30 VSS 1.93796f
C384 a_4812_6400.t0 VSS 0.80438f
C385 a_4812_6400.n31 VSS 0.244f
C386 a_4812_6400.t2 VSS 0.18016f
C387 a_4812_6400.t1 VSS 0.18016f
C388 a_4812_6400.n32 VSS 0.60167f
C389 a_4812_6400.n33 VSS 0.33909f
C390 a_4812_6400.t3 VSS 0.80983f
C391 a_6924_6400.t7 VSS 0.76986f
C392 a_6924_6400.t6 VSS 0.18097f
C393 a_6924_6400.t5 VSS 0.18097f
C394 a_6924_6400.n0 VSS 0.56534f
C395 a_6924_6400.n1 VSS 0.31075f
C396 a_6924_6400.t4 VSS 0.76478f
C397 a_6924_6400.n2 VSS 0.33562f
C398 a_6924_6400.n3 VSS 0.05226f
C399 a_6924_6400.n4 VSS 0.06203f
C400 a_6924_6400.n5 VSS 0.06203f
C401 a_6924_6400.n6 VSS 0.18054f
C402 a_6924_6400.n7 VSS 0.08924f
C403 a_6924_6400.n8 VSS 0.09565f
C404 a_6924_6400.n9 VSS 0.09565f
C405 a_6924_6400.n10 VSS 0.09565f
C406 a_6924_6400.n11 VSS 0.09565f
C407 a_6924_6400.n12 VSS 0.09565f
C408 a_6924_6400.n13 VSS 0.08924f
C409 a_6924_6400.n14 VSS 0.09565f
C410 a_6924_6400.n15 VSS 0.09565f
C411 a_6924_6400.n16 VSS 0.18054f
C412 a_6924_6400.n17 VSS 0.06203f
C413 a_6924_6400.n18 VSS 0.06203f
C414 a_6924_6400.n19 VSS 0.09565f
C415 a_6924_6400.n20 VSS 0.09565f
C416 a_6924_6400.n21 VSS 0.09565f
C417 a_6924_6400.n22 VSS 0.05226f
C418 a_6924_6400.n23 VSS 0.35576f
C419 a_6924_6400.n24 VSS 0.05226f
C420 a_6924_6400.n25 VSS 0.06203f
C421 a_6924_6400.n26 VSS 0.06203f
C422 a_6924_6400.n27 VSS 0.18054f
C423 a_6924_6400.n28 VSS 0.08924f
C424 a_6924_6400.n29 VSS 0.09565f
C425 a_6924_6400.n30 VSS 0.09565f
C426 a_6924_6400.n31 VSS 0.09565f
C427 a_6924_6400.n32 VSS 0.09565f
C428 a_6924_6400.n33 VSS 0.09565f
C429 a_6924_6400.n34 VSS 0.08924f
C430 a_6924_6400.n35 VSS 0.09565f
C431 a_6924_6400.n36 VSS 0.09565f
C432 a_6924_6400.n37 VSS 0.18054f
C433 a_6924_6400.n38 VSS 0.06203f
C434 a_6924_6400.n39 VSS 0.06203f
C435 a_6924_6400.n40 VSS 0.09565f
C436 a_6924_6400.n41 VSS 0.09565f
C437 a_6924_6400.n42 VSS 0.09565f
C438 a_6924_6400.n43 VSS 0.05226f
C439 a_6924_6400.n44 VSS 0.34996f
C440 a_6924_6400.n45 VSS 2.30382f
C441 a_6924_6400.n46 VSS 1.82128f
C442 a_6924_6400.t0 VSS 0.76343f
C443 a_6924_6400.n47 VSS 0.22757f
C444 a_6924_6400.t2 VSS 0.18097f
C445 a_6924_6400.t1 VSS 0.18097f
C446 a_6924_6400.n48 VSS 0.56117f
C447 a_6924_6400.n49 VSS 0.31627f
C448 a_6924_6400.t3 VSS 0.76851f
C449 a_14540_6400.t5 VSS 0.21265f
C450 a_14540_6400.t10 VSS 0.85893f
C451 a_14540_6400.t11 VSS 0.21265f
C452 a_14540_6400.t6 VSS 0.21265f
C453 a_14540_6400.n0 VSS 0.62017f
C454 a_14540_6400.n1 VSS 0.34089f
C455 a_14540_6400.t7 VSS 0.21265f
C456 a_14540_6400.t8 VSS 0.21265f
C457 a_14540_6400.n2 VSS 0.62017f
C458 a_14540_6400.n3 VSS 0.17795f
C459 a_14540_6400.t9 VSS 0.21265f
C460 a_14540_6400.t4 VSS 0.21265f
C461 a_14540_6400.n4 VSS 0.62017f
C462 a_14540_6400.n5 VSS 0.17795f
C463 a_14540_6400.n6 VSS 0.05733f
C464 a_14540_6400.n7 VSS 0.06804f
C465 a_14540_6400.n8 VSS 0.06804f
C466 a_14540_6400.n9 VSS 0.06804f
C467 a_14540_6400.n10 VSS 0.06804f
C468 a_14540_6400.n11 VSS 0.06804f
C469 a_14540_6400.n12 VSS 0.06804f
C470 a_14540_6400.n13 VSS 0.06804f
C471 a_14540_6400.n14 VSS 0.06804f
C472 a_14540_6400.n15 VSS 0.06804f
C473 a_14540_6400.n16 VSS 0.06804f
C474 a_14540_6400.n17 VSS 0.06804f
C475 a_14540_6400.n18 VSS 0.06804f
C476 a_14540_6400.n19 VSS 0.19805f
C477 a_14540_6400.n20 VSS 0.09789f
C478 a_14540_6400.n21 VSS 0.10493f
C479 a_14540_6400.n22 VSS 0.10493f
C480 a_14540_6400.n23 VSS 0.10493f
C481 a_14540_6400.n24 VSS 0.10493f
C482 a_14540_6400.n25 VSS 0.10493f
C483 a_14540_6400.n26 VSS 0.10493f
C484 a_14540_6400.n27 VSS 0.10493f
C485 a_14540_6400.n28 VSS 0.10493f
C486 a_14540_6400.n29 VSS 0.10493f
C487 a_14540_6400.n30 VSS 0.10493f
C488 a_14540_6400.n31 VSS 0.10493f
C489 a_14540_6400.n32 VSS 0.10493f
C490 a_14540_6400.n33 VSS 0.10493f
C491 a_14540_6400.n34 VSS 0.10493f
C492 a_14540_6400.n35 VSS 0.10493f
C493 a_14540_6400.n36 VSS 0.06804f
C494 a_14540_6400.n37 VSS 0.10493f
C495 a_14540_6400.n38 VSS 0.06804f
C496 a_14540_6400.n39 VSS 0.10493f
C497 a_14540_6400.n40 VSS 0.06804f
C498 a_14540_6400.n41 VSS 0.10493f
C499 a_14540_6400.n42 VSS 0.09789f
C500 a_14540_6400.n43 VSS 0.19805f
C501 a_14540_6400.n44 VSS 0.10493f
C502 a_14540_6400.n45 VSS 0.10493f
C503 a_14540_6400.n46 VSS 0.10493f
C504 a_14540_6400.n47 VSS 0.06804f
C505 a_14540_6400.n48 VSS 0.06804f
C506 a_14540_6400.n49 VSS 0.06804f
C507 a_14540_6400.n50 VSS 0.10493f
C508 a_14540_6400.n51 VSS 0.10493f
C509 a_14540_6400.n52 VSS 0.10493f
C510 a_14540_6400.n53 VSS 0.06804f
C511 a_14540_6400.n54 VSS 0.06804f
C512 a_14540_6400.n55 VSS 0.06804f
C513 a_14540_6400.n56 VSS 0.10493f
C514 a_14540_6400.n57 VSS 0.10493f
C515 a_14540_6400.n58 VSS 0.10493f
C516 a_14540_6400.n59 VSS 0.06804f
C517 a_14540_6400.n60 VSS 0.06804f
C518 a_14540_6400.n61 VSS 0.06804f
C519 a_14540_6400.n62 VSS 0.10493f
C520 a_14540_6400.n63 VSS 0.10493f
C521 a_14540_6400.n64 VSS 0.10493f
C522 a_14540_6400.n65 VSS 0.05733f
C523 a_14540_6400.n66 VSS 1.03896f
C524 a_14540_6400.n67 VSS 0.05733f
C525 a_14540_6400.n68 VSS 0.06804f
C526 a_14540_6400.n69 VSS 0.06804f
C527 a_14540_6400.n70 VSS 0.06804f
C528 a_14540_6400.n71 VSS 0.06804f
C529 a_14540_6400.n72 VSS 0.19805f
C530 a_14540_6400.n73 VSS 0.09789f
C531 a_14540_6400.n74 VSS 0.10493f
C532 a_14540_6400.n75 VSS 0.10493f
C533 a_14540_6400.n76 VSS 0.10493f
C534 a_14540_6400.n77 VSS 0.10493f
C535 a_14540_6400.n78 VSS 0.10493f
C536 a_14540_6400.n79 VSS 0.10493f
C537 a_14540_6400.n80 VSS 0.10493f
C538 a_14540_6400.n81 VSS 0.06804f
C539 a_14540_6400.n82 VSS 0.10493f
C540 a_14540_6400.n83 VSS 0.09789f
C541 a_14540_6400.n84 VSS 0.19805f
C542 a_14540_6400.n85 VSS 0.10493f
C543 a_14540_6400.n86 VSS 0.10493f
C544 a_14540_6400.n87 VSS 0.10493f
C545 a_14540_6400.n88 VSS 0.06804f
C546 a_14540_6400.n89 VSS 0.06804f
C547 a_14540_6400.n90 VSS 0.06804f
C548 a_14540_6400.n91 VSS 0.10493f
C549 a_14540_6400.n92 VSS 0.10493f
C550 a_14540_6400.n93 VSS 0.10493f
C551 a_14540_6400.n94 VSS 0.05733f
C552 a_14540_6400.n95 VSS 0.45288f
C553 a_14540_6400.n96 VSS 2.74379f
C554 a_14540_6400.t23 VSS 0.85744f
C555 a_14540_6400.t22 VSS 0.21265f
C556 a_14540_6400.t20 VSS 0.21265f
C557 a_14540_6400.n97 VSS 0.6156f
C558 a_14540_6400.n98 VSS 0.34694f
C559 a_14540_6400.t21 VSS 0.21265f
C560 a_14540_6400.t2 VSS 0.21265f
C561 a_14540_6400.n99 VSS 0.6156f
C562 a_14540_6400.n100 VSS 0.18252f
C563 a_14540_6400.t3 VSS 0.21265f
C564 a_14540_6400.t14 VSS 0.21265f
C565 a_14540_6400.n101 VSS 0.6156f
C566 a_14540_6400.n102 VSS 0.18252f
C567 a_14540_6400.t15 VSS 0.21265f
C568 a_14540_6400.t16 VSS 0.21265f
C569 a_14540_6400.n103 VSS 0.6156f
C570 a_14540_6400.n104 VSS 0.18252f
C571 a_14540_6400.t17 VSS 0.21265f
C572 a_14540_6400.t18 VSS 0.21265f
C573 a_14540_6400.n105 VSS 0.6156f
C574 a_14540_6400.n106 VSS 0.18252f
C575 a_14540_6400.t19 VSS 0.85187f
C576 a_14540_6400.n107 VSS 0.24965f
C577 a_14540_6400.n108 VSS 1.8781f
C578 a_14540_6400.t13 VSS 0.85336f
C579 a_14540_6400.n109 VSS 0.36817f
C580 a_14540_6400.t1 VSS 0.21265f
C581 a_14540_6400.t12 VSS 0.21265f
C582 a_14540_6400.n110 VSS 0.62017f
C583 a_14540_6400.n111 VSS 0.17795f
C584 a_14540_6400.n112 VSS 0.17795f
C585 a_14540_6400.n113 VSS 0.62017f
C586 a_14540_6400.t0 VSS 0.21265f
C587 VSS.t3 VSS 0.10185f
C588 VSS.t195 VSS 0.1038f
C589 VSS.t61 VSS 0.10185f
C590 VSS.t1 VSS 0.10185f
C591 VSS.t211 VSS 0.10185f
C592 VSS.t59 VSS 0.10185f
C593 VSS.t87 VSS 0.10185f
C594 VSS.t209 VSS 0.10185f
C595 VSS.t203 VSS 0.10185f
C596 VSS.t85 VSS 0.10185f
C597 VSS.t91 VSS 0.10185f
C598 VSS.t201 VSS 0.10185f
C599 VSS.t179 VSS 0.10185f
C600 VSS.t89 VSS 0.10185f
C601 VSS.t157 VSS 0.1038f
C602 VSS.t177 VSS 0.10185f
C603 VSS.t167 VSS 0.09284f
C604 VSS.t169 VSS 0.09462f
C605 VSS.t163 VSS 0.09284f
C606 VSS.t165 VSS 0.09284f
C607 VSS.t159 VSS 0.09284f
C608 VSS.t161 VSS 0.09284f
C609 VSS.t75 VSS 0.09284f
C610 VSS.t77 VSS 0.09284f
C611 VSS.t183 VSS 0.09284f
C612 VSS.t185 VSS 0.09284f
C613 VSS.t197 VSS 0.09462f
C614 VSS.t191 VSS 0.09284f
C615 VSS.t37 VSS 0.09954f
C616 VSS.t63 VSS 0.10145f
C617 VSS.t7 VSS 0.09954f
C618 VSS.t35 VSS 0.09954f
C619 VSS.t23 VSS 0.09954f
C620 VSS.t5 VSS 0.09954f
C621 VSS.t65 VSS 0.10145f
C622 VSS.t21 VSS 0.09954f
C623 VSS.t43 VSS 0.09551f
C624 VSS.t175 VSS 0.09734f
C625 VSS.t207 VSS 0.09551f
C626 VSS.t205 VSS 0.09551f
C627 VSS.t223 VSS 0.09551f
C628 VSS.t45 VSS 0.09551f
C629 VSS.t155 VSS 0.09734f
C630 VSS.t55 VSS 0.09551f
C631 VSS.t119 VSS 0.07175f
C632 VSS.t109 VSS 0.07313f
C633 VSS.t123 VSS 0.07313f
C634 VSS.t121 VSS 0.07175f
C635 VSS.t137 VSS 0.06306f
C636 VSS.t135 VSS 0.06427f
C637 VSS.t133 VSS 0.06427f
C638 VSS.t131 VSS 0.06306f
C639 VSS.t113 VSS 0.07175f
C640 VSS.t111 VSS 0.07313f
C641 VSS.t117 VSS 0.07313f
C642 VSS.t115 VSS 0.07175f
C643 VSS.t97 VSS 0.07037f
C644 VSS.t95 VSS 0.07172f
C645 VSS.t101 VSS 0.07172f
C646 VSS.t99 VSS 0.07037f
C647 VSS.t149 VSS 0.06306f
C648 VSS.t153 VSS 0.06427f
C649 VSS.t151 VSS 0.06427f
C650 VSS.t147 VSS 0.06306f
C651 VSS.t103 VSS 0.07037f
C652 VSS.t93 VSS 0.07172f
C653 VSS.t107 VSS 0.07172f
C654 VSS.t105 VSS 0.07037f
C655 VSS.t129 VSS 0.09551f
C656 VSS.t33 VSS 0.09734f
C657 VSS.t181 VSS 0.09551f
C658 VSS.t57 VSS 0.09551f
C659 VSS.t187 VSS 0.09551f
C660 VSS.t19 VSS 0.09551f
C661 VSS.t189 VSS 0.09734f
C662 VSS.t193 VSS 0.09551f
C663 VSS.t47 VSS 0.09954f
C664 VSS.t49 VSS 0.10145f
C665 VSS.t15 VSS 0.09954f
C666 VSS.t17 VSS 0.09954f
C667 VSS.t125 VSS 0.09954f
C668 VSS.t127 VSS 0.09954f
C669 VSS.t51 VSS 0.10145f
C670 VSS.t53 VSS 0.09954f
C671 VSS.t139 VSS 0.09284f
C672 VSS.t141 VSS 0.09462f
C673 VSS.t219 VSS 0.09284f
C674 VSS.t221 VSS 0.09284f
C675 VSS.t143 VSS 0.09284f
C676 VSS.t145 VSS 0.09284f
C677 VSS.t215 VSS 0.09284f
C678 VSS.t217 VSS 0.09284f
C679 VSS.t171 VSS 0.09284f
C680 VSS.t173 VSS 0.09284f
C681 VSS.t213 VSS 0.09462f
C682 VSS.t13 VSS 0.09284f
C683 VSS.t27 VSS 0.10185f
C684 VSS.t199 VSS 0.1038f
C685 VSS.t69 VSS 0.10185f
C686 VSS.t25 VSS 0.10185f
C687 VSS.t81 VSS 0.10185f
C688 VSS.t67 VSS 0.10185f
C689 VSS.t41 VSS 0.10185f
C690 VSS.t79 VSS 0.10185f
C691 VSS.t11 VSS 0.10185f
C692 VSS.t39 VSS 0.10185f
C693 VSS.t31 VSS 0.10185f
C694 VSS.t9 VSS 0.10185f
C695 VSS.t73 VSS 0.10185f
C696 VSS.t29 VSS 0.10185f
C697 VSS.t83 VSS 0.1038f
C698 VSS.t71 VSS 0.10185f
C699 VDD.n1 VSS 1.17681f
C700 VDD.t158 VSS 0.64218f
C701 VDD.t154 VSS 0.11457f
C702 VDD.t156 VSS 0.11457f
C703 VDD.t160 VSS 0.64161f
C704 VDD.t206 VSS 0.64161f
C705 VDD.t208 VSS 0.11457f
C706 VDD.t210 VSS 0.11457f
C707 VDD.t212 VSS 0.64161f
C708 VDD.t152 VSS 0.64161f
C709 VDD.t150 VSS 0.11457f
C710 VDD.t162 VSS 0.11457f
C711 VDD.t148 VSS 0.64161f
C712 VDD.t214 VSS 0.64161f
C713 VDD.t96 VSS 0.11457f
C714 VDD.t10 VSS 0.11457f
C715 VDD.t36 VSS 0.11457f
C716 VDD.t12 VSS 0.11457f
C717 VDD.t72 VSS 0.11457f
C718 VDD.t74 VSS 0.11457f
C719 VDD.t216 VSS 0.64161f
C720 VDD.t18 VSS 0.64161f
C721 VDD.t78 VSS 0.11457f
C722 VDD.t76 VSS 0.11457f
C723 VDD.t258 VSS 0.11457f
C724 VDD.t256 VSS 0.11457f
C725 VDD.t22 VSS 0.11457f
C726 VDD.t20 VSS 0.11457f
C727 VDD.t80 VSS 0.64161f
C728 VDD.t190 VSS 0.64161f
C729 VDD.t188 VSS 0.11457f
C730 VDD.t100 VSS 0.11457f
C731 VDD.t98 VSS 0.11457f
C732 VDD.t112 VSS 0.11457f
C733 VDD.t110 VSS 0.11457f
C734 VDD.t170 VSS 0.11457f
C735 VDD.t168 VSS 0.11457f
C736 VDD.t116 VSS 0.11457f
C737 VDD.t114 VSS 0.11457f
C738 VDD.t184 VSS 0.11457f
C739 VDD.t182 VSS 0.64161f
C740 VDD.t186 VSS 0.64161f
C741 VDD.t268 VSS 0.11457f
C742 VDD.t200 VSS 0.11457f
C743 VDD.t0 VSS 0.11457f
C744 VDD.t218 VSS 0.11457f
C745 VDD.t70 VSS 0.11457f
C746 VDD.t278 VSS 0.11457f
C747 VDD.t58 VSS 0.11457f
C748 VDD.t56 VSS 0.11457f
C749 VDD.t16 VSS 0.11457f
C750 VDD.t14 VSS 0.11457f
C751 VDD.t126 VSS 0.11457f
C752 VDD.t124 VSS 0.11457f
C753 VDD.t166 VSS 0.11457f
C754 VDD.t164 VSS 0.11457f
C755 VDD.t226 VSS 0.11457f
C756 VDD.t224 VSS 0.11457f
C757 VDD.t272 VSS 0.11457f
C758 VDD.t270 VSS 0.11457f
C759 VDD.t204 VSS 0.11457f
C760 VDD.t202 VSS 0.11457f
C761 VDD.t222 VSS 0.11457f
C762 VDD.t220 VSS 0.11457f
C763 VDD.t282 VSS 0.11457f
C764 VDD.t280 VSS 0.11457f
C765 VDD.t130 VSS 0.11457f
C766 VDD.t128 VSS 0.11457f
C767 VDD.t180 VSS 0.11457f
C768 VDD.t178 VSS 0.11457f
C769 VDD.t230 VSS 0.11457f
C770 VDD.t228 VSS 0.11457f
C771 VDD.t264 VSS 0.55936f
C772 VDD.n2 VSS 3.16726f
C773 VDD.t269 VSS 0.11007f
C774 VDD.t187 VSS 0.11203f
C775 VDD.n3 VSS 0.04293f
C776 VDD.t1 VSS 0.11007f
C777 VDD.t201 VSS 0.11007f
C778 VDD.n4 VSS 0.0426f
C779 VDD.n5 VSS 0.02159f
C780 VDD.t71 VSS 0.11007f
C781 VDD.t219 VSS 0.11007f
C782 VDD.n6 VSS 0.0426f
C783 VDD.n7 VSS 0.01222f
C784 VDD.t59 VSS 0.11007f
C785 VDD.t279 VSS 0.11007f
C786 VDD.n8 VSS 0.0426f
C787 VDD.n9 VSS 0.01222f
C788 VDD.t17 VSS 0.11007f
C789 VDD.t57 VSS 0.11007f
C790 VDD.n10 VSS 0.0426f
C791 VDD.n11 VSS 0.01222f
C792 VDD.t127 VSS 0.11007f
C793 VDD.t15 VSS 0.11007f
C794 VDD.n12 VSS 0.0426f
C795 VDD.n13 VSS 0.01222f
C796 VDD.t167 VSS 0.11007f
C797 VDD.t125 VSS 0.11007f
C798 VDD.n14 VSS 0.0426f
C799 VDD.n15 VSS 0.01222f
C800 VDD.t227 VSS 0.11007f
C801 VDD.t165 VSS 0.11007f
C802 VDD.n16 VSS 0.0426f
C803 VDD.n17 VSS 0.01222f
C804 VDD.t273 VSS 0.11007f
C805 VDD.t225 VSS 0.11007f
C806 VDD.n18 VSS 0.0426f
C807 VDD.n19 VSS 0.01222f
C808 VDD.t205 VSS 0.11007f
C809 VDD.t271 VSS 0.11007f
C810 VDD.n20 VSS 0.0426f
C811 VDD.n21 VSS 0.01222f
C812 VDD.t223 VSS 0.11007f
C813 VDD.t203 VSS 0.11007f
C814 VDD.n22 VSS 0.0426f
C815 VDD.n23 VSS 0.01222f
C816 VDD.t283 VSS 0.11007f
C817 VDD.t221 VSS 0.11007f
C818 VDD.n24 VSS 0.0426f
C819 VDD.n25 VSS 0.01222f
C820 VDD.t131 VSS 0.11007f
C821 VDD.t281 VSS 0.11007f
C822 VDD.n26 VSS 0.0426f
C823 VDD.n27 VSS 0.01222f
C824 VDD.t181 VSS 0.11007f
C825 VDD.t129 VSS 0.11007f
C826 VDD.n28 VSS 0.0426f
C827 VDD.n29 VSS 0.01222f
C828 VDD.t231 VSS 0.11007f
C829 VDD.t179 VSS 0.11007f
C830 VDD.n30 VSS 0.0426f
C831 VDD.n31 VSS 0.01222f
C832 VDD.t265 VSS 0.11203f
C833 VDD.t229 VSS 0.11007f
C834 VDD.n32 VSS 0.0426f
C835 VDD.n33 VSS 0.04771f
C836 VDD.n34 VSS 0.59051f
C837 VDD.t189 VSS 0.10107f
C838 VDD.t191 VSS 0.10285f
C839 VDD.n35 VSS 0.04293f
C840 VDD.t99 VSS 0.10107f
C841 VDD.t101 VSS 0.10107f
C842 VDD.n36 VSS 0.0426f
C843 VDD.n37 VSS 0.02159f
C844 VDD.t111 VSS 0.10107f
C845 VDD.t113 VSS 0.10107f
C846 VDD.n38 VSS 0.0426f
C847 VDD.n39 VSS 0.01222f
C848 VDD.t169 VSS 0.10107f
C849 VDD.t171 VSS 0.10107f
C850 VDD.n40 VSS 0.0426f
C851 VDD.n41 VSS 0.01222f
C852 VDD.t115 VSS 0.10107f
C853 VDD.t117 VSS 0.10107f
C854 VDD.n42 VSS 0.0426f
C855 VDD.n43 VSS 0.01222f
C856 VDD.t183 VSS 0.10285f
C857 VDD.t185 VSS 0.10107f
C858 VDD.n44 VSS 0.0426f
C859 VDD.n45 VSS 0.04771f
C860 VDD.n46 VSS 0.81892f
C861 VDD.t79 VSS 0.10777f
C862 VDD.t19 VSS 0.10968f
C863 VDD.n47 VSS 0.04293f
C864 VDD.t259 VSS 0.10777f
C865 VDD.t77 VSS 0.10777f
C866 VDD.n48 VSS 0.0426f
C867 VDD.n49 VSS 0.02159f
C868 VDD.t23 VSS 0.10777f
C869 VDD.t257 VSS 0.10777f
C870 VDD.n50 VSS 0.0426f
C871 VDD.n51 VSS 0.01222f
C872 VDD.t81 VSS 0.10968f
C873 VDD.t21 VSS 0.10777f
C874 VDD.n52 VSS 0.0426f
C875 VDD.n53 VSS 0.04771f
C876 VDD.n54 VSS 0.51507f
C877 VDD.t97 VSS 0.10374f
C878 VDD.t215 VSS 0.10557f
C879 VDD.n55 VSS 0.04293f
C880 VDD.t37 VSS 0.10374f
C881 VDD.t11 VSS 0.10374f
C882 VDD.n56 VSS 0.0426f
C883 VDD.n57 VSS 0.02159f
C884 VDD.t73 VSS 0.10374f
C885 VDD.t13 VSS 0.10374f
C886 VDD.n58 VSS 0.0426f
C887 VDD.n59 VSS 0.01222f
C888 VDD.t217 VSS 0.10557f
C889 VDD.t75 VSS 0.10374f
C890 VDD.n60 VSS 0.0426f
C891 VDD.n61 VSS 0.04771f
C892 VDD.n62 VSS 0.46443f
C893 VDD.t151 VSS 0.07998f
C894 VDD.t153 VSS 0.08136f
C895 VDD.n63 VSS 0.04293f
C896 VDD.t149 VSS 0.08136f
C897 VDD.t163 VSS 0.07998f
C898 VDD.n64 VSS 0.0426f
C899 VDD.n65 VSS 0.05708f
C900 VDD.n66 VSS 0.41379f
C901 VDD.t209 VSS 0.07129f
C902 VDD.t207 VSS 0.0725f
C903 VDD.n67 VSS 0.04293f
C904 VDD.t213 VSS 0.0725f
C905 VDD.t211 VSS 0.07129f
C906 VDD.n68 VSS 0.0426f
C907 VDD.n69 VSS 0.05708f
C908 VDD.n70 VSS 0.36315f
C909 VDD.t155 VSS 0.07998f
C910 VDD.t159 VSS 0.08136f
C911 VDD.n71 VSS 0.04293f
C912 VDD.t161 VSS 0.08136f
C913 VDD.t157 VSS 0.07998f
C914 VDD.n72 VSS 0.0426f
C915 VDD.n73 VSS 0.05708f
C916 VDD.n74 VSS 0.36236f
C917 VDD.n75 VSS 0.17107f
C918 VDD.n76 VSS 4.84417f
C919 VDD.n77 VSS 30.4384f
C920 VDD.n78 VSS 64.4933f
C921 VDD.n79 VSS 1.17681f
C922 VDD.t142 VSS 0.64218f
C923 VDD.t140 VSS 0.11457f
C924 VDD.t138 VSS 0.11457f
C925 VDD.t144 VSS 0.64161f
C926 VDD.t232 VSS 0.64161f
C927 VDD.t234 VSS 0.11457f
C928 VDD.t236 VSS 0.11457f
C929 VDD.t238 VSS 0.64161f
C930 VDD.t136 VSS 0.64161f
C931 VDD.t134 VSS 0.11457f
C932 VDD.t146 VSS 0.11457f
C933 VDD.t132 VSS 0.64161f
C934 VDD.t64 VSS 0.64161f
C935 VDD.t44 VSS 0.11457f
C936 VDD.t42 VSS 0.11457f
C937 VDD.t198 VSS 0.11457f
C938 VDD.t196 VSS 0.11457f
C939 VDD.t68 VSS 0.11457f
C940 VDD.t66 VSS 0.11457f
C941 VDD.t46 VSS 0.64161f
C942 VDD.t194 VSS 0.64161f
C943 VDD.t192 VSS 0.11457f
C944 VDD.t62 VSS 0.11457f
C945 VDD.t60 VSS 0.11457f
C946 VDD.t40 VSS 0.11457f
C947 VDD.t38 VSS 0.11457f
C948 VDD.t176 VSS 0.11457f
C949 VDD.t174 VSS 0.64161f
C950 VDD.t250 VSS 0.64161f
C951 VDD.t248 VSS 0.11457f
C952 VDD.t286 VSS 0.11457f
C953 VDD.t284 VSS 0.11457f
C954 VDD.t242 VSS 0.11457f
C955 VDD.t240 VSS 0.11457f
C956 VDD.t246 VSS 0.11457f
C957 VDD.t244 VSS 0.11457f
C958 VDD.t254 VSS 0.11457f
C959 VDD.t252 VSS 0.11457f
C960 VDD.t276 VSS 0.11457f
C961 VDD.t274 VSS 0.64161f
C962 VDD.t82 VSS 0.64161f
C963 VDD.t172 VSS 0.11457f
C964 VDD.t122 VSS 0.11457f
C965 VDD.t262 VSS 0.11457f
C966 VDD.t260 VSS 0.11457f
C967 VDD.t108 VSS 0.11457f
C968 VDD.t106 VSS 0.11457f
C969 VDD.t26 VSS 0.11457f
C970 VDD.t24 VSS 0.11457f
C971 VDD.t86 VSS 0.11457f
C972 VDD.t84 VSS 0.11457f
C973 VDD.t50 VSS 0.11457f
C974 VDD.t48 VSS 0.11457f
C975 VDD.t4 VSS 0.11457f
C976 VDD.t2 VSS 0.11457f
C977 VDD.t30 VSS 0.11457f
C978 VDD.t28 VSS 0.11457f
C979 VDD.t90 VSS 0.11457f
C980 VDD.t88 VSS 0.11457f
C981 VDD.t104 VSS 0.11457f
C982 VDD.t102 VSS 0.11457f
C983 VDD.t54 VSS 0.11457f
C984 VDD.t52 VSS 0.11457f
C985 VDD.t8 VSS 0.11457f
C986 VDD.t6 VSS 0.11457f
C987 VDD.t34 VSS 0.11457f
C988 VDD.t32 VSS 0.11457f
C989 VDD.t94 VSS 0.11457f
C990 VDD.t92 VSS 0.11457f
C991 VDD.t120 VSS 0.11457f
C992 VDD.t118 VSS 0.11457f
C993 VDD.t266 VSS 0.55936f
C994 VDD.n80 VSS 3.16726f
C995 VDD.t173 VSS 0.11007f
C996 VDD.t83 VSS 0.11203f
C997 VDD.n81 VSS 0.04293f
C998 VDD.t263 VSS 0.11007f
C999 VDD.t123 VSS 0.11007f
C1000 VDD.n82 VSS 0.0426f
C1001 VDD.n83 VSS 0.02159f
C1002 VDD.t109 VSS 0.11007f
C1003 VDD.t261 VSS 0.11007f
C1004 VDD.n84 VSS 0.0426f
C1005 VDD.n85 VSS 0.01222f
C1006 VDD.t27 VSS 0.11007f
C1007 VDD.t107 VSS 0.11007f
C1008 VDD.n86 VSS 0.0426f
C1009 VDD.n87 VSS 0.01222f
C1010 VDD.t87 VSS 0.11007f
C1011 VDD.t25 VSS 0.11007f
C1012 VDD.n88 VSS 0.0426f
C1013 VDD.n89 VSS 0.01222f
C1014 VDD.t51 VSS 0.11007f
C1015 VDD.t85 VSS 0.11007f
C1016 VDD.n90 VSS 0.0426f
C1017 VDD.n91 VSS 0.01222f
C1018 VDD.t5 VSS 0.11007f
C1019 VDD.t49 VSS 0.11007f
C1020 VDD.n92 VSS 0.0426f
C1021 VDD.n93 VSS 0.01222f
C1022 VDD.t31 VSS 0.11007f
C1023 VDD.t3 VSS 0.11007f
C1024 VDD.n94 VSS 0.0426f
C1025 VDD.n95 VSS 0.01222f
C1026 VDD.t91 VSS 0.11007f
C1027 VDD.t29 VSS 0.11007f
C1028 VDD.n96 VSS 0.0426f
C1029 VDD.n97 VSS 0.01222f
C1030 VDD.t105 VSS 0.11007f
C1031 VDD.t89 VSS 0.11007f
C1032 VDD.n98 VSS 0.0426f
C1033 VDD.n99 VSS 0.01222f
C1034 VDD.t55 VSS 0.11007f
C1035 VDD.t103 VSS 0.11007f
C1036 VDD.n100 VSS 0.0426f
C1037 VDD.n101 VSS 0.01222f
C1038 VDD.t9 VSS 0.11007f
C1039 VDD.t53 VSS 0.11007f
C1040 VDD.n102 VSS 0.0426f
C1041 VDD.n103 VSS 0.01222f
C1042 VDD.t35 VSS 0.11007f
C1043 VDD.t7 VSS 0.11007f
C1044 VDD.n104 VSS 0.0426f
C1045 VDD.n105 VSS 0.01222f
C1046 VDD.t95 VSS 0.11007f
C1047 VDD.t33 VSS 0.11007f
C1048 VDD.n106 VSS 0.0426f
C1049 VDD.n107 VSS 0.01222f
C1050 VDD.t121 VSS 0.11007f
C1051 VDD.t93 VSS 0.11007f
C1052 VDD.n108 VSS 0.0426f
C1053 VDD.n109 VSS 0.01222f
C1054 VDD.t267 VSS 0.11203f
C1055 VDD.t119 VSS 0.11007f
C1056 VDD.n110 VSS 0.0426f
C1057 VDD.n111 VSS 0.04771f
C1058 VDD.n112 VSS 0.59051f
C1059 VDD.t249 VSS 0.10107f
C1060 VDD.t251 VSS 0.10285f
C1061 VDD.n113 VSS 0.04293f
C1062 VDD.t285 VSS 0.10107f
C1063 VDD.t287 VSS 0.10107f
C1064 VDD.n114 VSS 0.0426f
C1065 VDD.n115 VSS 0.02159f
C1066 VDD.t241 VSS 0.10107f
C1067 VDD.t243 VSS 0.10107f
C1068 VDD.n116 VSS 0.0426f
C1069 VDD.n117 VSS 0.01222f
C1070 VDD.t245 VSS 0.10107f
C1071 VDD.t247 VSS 0.10107f
C1072 VDD.n118 VSS 0.0426f
C1073 VDD.n119 VSS 0.01222f
C1074 VDD.t253 VSS 0.10107f
C1075 VDD.t255 VSS 0.10107f
C1076 VDD.n120 VSS 0.0426f
C1077 VDD.n121 VSS 0.01222f
C1078 VDD.t275 VSS 0.10285f
C1079 VDD.t277 VSS 0.10107f
C1080 VDD.n122 VSS 0.0426f
C1081 VDD.n123 VSS 0.04771f
C1082 VDD.n124 VSS 0.81892f
C1083 VDD.t193 VSS 0.10777f
C1084 VDD.t195 VSS 0.10968f
C1085 VDD.n125 VSS 0.04293f
C1086 VDD.t61 VSS 0.10777f
C1087 VDD.t63 VSS 0.10777f
C1088 VDD.n126 VSS 0.0426f
C1089 VDD.n127 VSS 0.02159f
C1090 VDD.t39 VSS 0.10777f
C1091 VDD.t41 VSS 0.10777f
C1092 VDD.n128 VSS 0.0426f
C1093 VDD.n129 VSS 0.01222f
C1094 VDD.t175 VSS 0.10968f
C1095 VDD.t177 VSS 0.10777f
C1096 VDD.n130 VSS 0.0426f
C1097 VDD.n131 VSS 0.04771f
C1098 VDD.n132 VSS 0.51507f
C1099 VDD.t45 VSS 0.10374f
C1100 VDD.t65 VSS 0.10557f
C1101 VDD.n133 VSS 0.04293f
C1102 VDD.t199 VSS 0.10374f
C1103 VDD.t43 VSS 0.10374f
C1104 VDD.n134 VSS 0.0426f
C1105 VDD.n135 VSS 0.02159f
C1106 VDD.t69 VSS 0.10374f
C1107 VDD.t197 VSS 0.10374f
C1108 VDD.n136 VSS 0.0426f
C1109 VDD.n137 VSS 0.01222f
C1110 VDD.t47 VSS 0.10557f
C1111 VDD.t67 VSS 0.10374f
C1112 VDD.n138 VSS 0.0426f
C1113 VDD.n139 VSS 0.04771f
C1114 VDD.n140 VSS 0.46443f
C1115 VDD.t135 VSS 0.0786f
C1116 VDD.t137 VSS 0.07995f
C1117 VDD.n141 VSS 0.04293f
C1118 VDD.t133 VSS 0.07995f
C1119 VDD.t147 VSS 0.0786f
C1120 VDD.n142 VSS 0.0426f
C1121 VDD.n143 VSS 0.05708f
C1122 VDD.n144 VSS 0.41379f
C1123 VDD.t235 VSS 0.07129f
C1124 VDD.t233 VSS 0.0725f
C1125 VDD.n145 VSS 0.04293f
C1126 VDD.t239 VSS 0.0725f
C1127 VDD.t237 VSS 0.07129f
C1128 VDD.n146 VSS 0.0426f
C1129 VDD.n147 VSS 0.05708f
C1130 VDD.n148 VSS 0.36315f
C1131 VDD.t141 VSS 0.0786f
C1132 VDD.t143 VSS 0.07995f
C1133 VDD.n149 VSS 0.04293f
C1134 VDD.t145 VSS 0.07995f
C1135 VDD.t139 VSS 0.0786f
C1136 VDD.n150 VSS 0.0426f
C1137 VDD.n151 VSS 0.05708f
C1138 VDD.n152 VSS 0.36236f
C1139 VDD.n153 VSS 0.17107f
C1140 VDD.n154 VSS 4.84417f
C1141 VDD.n155 VSS 30.0239f
C1142 VDD.n156 VSS 64.90781f
C1143 VDD.n158 VSS 0.01144f
C1144 CLKN_HB.n0 VSS 0.06668f
C1145 CLKN_HB.n1 VSS 0.0725f
C1146 CLKN_HB.n2 VSS 0.0725f
C1147 CLKN_HB.n3 VSS 0.06668f
C1148 CLKN_HB.n4 VSS 0.31828f
C1149 CLKN_HB.n5 VSS 0.06668f
C1150 CLKN_HB.n6 VSS 0.0725f
C1151 CLKN_HB.n7 VSS 0.0725f
C1152 CLKN_HB.n8 VSS 0.06668f
C1153 CLKN_HB.n9 VSS 0.25723f
C1154 CLKN_HB.n10 VSS 0.84853f
C1155 CLKN_HB.n11 VSS 0.06668f
C1156 CLKN_HB.n12 VSS 0.0725f
C1157 CLKN_HB.n13 VSS 0.0725f
C1158 CLKN_HB.n14 VSS 0.06668f
C1159 CLKN_HB.n15 VSS 0.31828f
C1160 CLKN_HB.n16 VSS 0.06668f
C1161 CLKN_HB.n17 VSS 0.0725f
C1162 CLKN_HB.n18 VSS 0.0725f
C1163 CLKN_HB.n19 VSS 0.06668f
C1164 CLKN_HB.n20 VSS 0.25723f
C1165 CLKN_HB.n21 VSS 0.657f
C1166 CLKN_HB.n22 VSS 1.26044f
C1167 CLKN_H.n0 VSS 0.05975f
C1168 CLKN_H.n1 VSS 0.06497f
C1169 CLKN_H.n2 VSS 0.06497f
C1170 CLKN_H.n3 VSS 0.05975f
C1171 CLKN_H.n4 VSS 0.28519f
C1172 CLKN_H.n5 VSS 0.05975f
C1173 CLKN_H.n6 VSS 0.06497f
C1174 CLKN_H.n7 VSS 0.06497f
C1175 CLKN_H.n8 VSS 0.05975f
C1176 CLKN_H.n9 VSS 0.23049f
C1177 CLKN_H.n10 VSS 1.74315f
C1178 O_CAPTURE_CLKB.t4 VSS 1.05925f
C1179 O_CAPTURE_CLKB.t6 VSS 0.24629f
C1180 O_CAPTURE_CLKB.t7 VSS 0.24629f
C1181 O_CAPTURE_CLKB.n0 VSS 0.78051f
C1182 O_CAPTURE_CLKB.n1 VSS 0.42902f
C1183 O_CAPTURE_CLKB.t9 VSS 0.24629f
C1184 O_CAPTURE_CLKB.t10 VSS 0.24629f
C1185 O_CAPTURE_CLKB.n2 VSS 0.78051f
C1186 O_CAPTURE_CLKB.n3 VSS 0.22396f
C1187 O_CAPTURE_CLKB.t1 VSS 0.24629f
C1188 O_CAPTURE_CLKB.t2 VSS 0.24629f
C1189 O_CAPTURE_CLKB.n4 VSS 0.78051f
C1190 O_CAPTURE_CLKB.n5 VSS 0.22396f
C1191 O_CAPTURE_CLKB.t5 VSS 1.05224f
C1192 O_CAPTURE_CLKB.n6 VSS 0.46336f
C1193 O_CAPTURE_CLKB.t14 VSS 1.05738f
C1194 O_CAPTURE_CLKB.t15 VSS 0.24629f
C1195 O_CAPTURE_CLKB.t13 VSS 0.24629f
C1196 O_CAPTURE_CLKB.n7 VSS 0.77475f
C1197 O_CAPTURE_CLKB.n8 VSS 0.43664f
C1198 O_CAPTURE_CLKB.t0 VSS 0.24629f
C1199 O_CAPTURE_CLKB.t12 VSS 0.24629f
C1200 O_CAPTURE_CLKB.n9 VSS 0.77475f
C1201 O_CAPTURE_CLKB.n10 VSS 0.22971f
C1202 O_CAPTURE_CLKB.t8 VSS 0.24629f
C1203 O_CAPTURE_CLKB.t11 VSS 0.24629f
C1204 O_CAPTURE_CLKB.n11 VSS 0.77475f
C1205 O_CAPTURE_CLKB.n12 VSS 0.22971f
C1206 O_CAPTURE_CLKB.t3 VSS 1.05037f
C1207 O_CAPTURE_CLKB.n13 VSS 0.31419f
C1208 O_CAPTURE_CLKB.n14 VSS 1.0083f
C1209 O_CAPTURE_CLK.t10 VSS 1.02088f
C1210 O_CAPTURE_CLK.t11 VSS 0.24367f
C1211 O_CAPTURE_CLK.t2 VSS 0.24367f
C1212 O_CAPTURE_CLK.n0 VSS 0.74604f
C1213 O_CAPTURE_CLK.n1 VSS 0.41008f
C1214 O_CAPTURE_CLK.t3 VSS 0.24367f
C1215 O_CAPTURE_CLK.t8 VSS 0.24367f
C1216 O_CAPTURE_CLK.n2 VSS 0.74604f
C1217 O_CAPTURE_CLK.n3 VSS 0.21407f
C1218 O_CAPTURE_CLK.t9 VSS 0.24367f
C1219 O_CAPTURE_CLK.t14 VSS 0.24367f
C1220 O_CAPTURE_CLK.n4 VSS 0.74604f
C1221 O_CAPTURE_CLK.n5 VSS 0.21407f
C1222 O_CAPTURE_CLK.t15 VSS 1.01419f
C1223 O_CAPTURE_CLK.n6 VSS 0.4429f
C1224 O_CAPTURE_CLK.t6 VSS 1.0191f
C1225 O_CAPTURE_CLK.t7 VSS 0.24367f
C1226 O_CAPTURE_CLK.t12 VSS 0.24367f
C1227 O_CAPTURE_CLK.n7 VSS 0.74054f
C1228 O_CAPTURE_CLK.n8 VSS 0.41736f
C1229 O_CAPTURE_CLK.t13 VSS 0.24367f
C1230 O_CAPTURE_CLK.t0 VSS 0.24367f
C1231 O_CAPTURE_CLK.n9 VSS 0.74054f
C1232 O_CAPTURE_CLK.n10 VSS 0.21957f
C1233 O_CAPTURE_CLK.t1 VSS 0.24367f
C1234 O_CAPTURE_CLK.t4 VSS 0.24367f
C1235 O_CAPTURE_CLK.n11 VSS 0.74054f
C1236 O_CAPTURE_CLK.n12 VSS 0.21957f
C1237 O_CAPTURE_CLK.t5 VSS 1.0124f
C1238 O_CAPTURE_CLK.n13 VSS 0.30032f
C1239 O_CAPTURE_CLK.n14 VSS 1.53502f
C1240 O_SENSE.t47 VSS 1.31052f
C1241 O_SENSE.t37 VSS 0.29101f
C1242 O_SENSE.t38 VSS 0.29101f
C1243 O_SENSE.n0 VSS 0.97915f
C1244 O_SENSE.n1 VSS 0.53821f
C1245 O_SENSE.t27 VSS 0.29101f
C1246 O_SENSE.t28 VSS 0.29101f
C1247 O_SENSE.n2 VSS 0.97915f
C1248 O_SENSE.n3 VSS 0.28096f
C1249 O_SENSE.t10 VSS 0.29101f
C1250 O_SENSE.t11 VSS 0.29101f
C1251 O_SENSE.n4 VSS 0.97915f
C1252 O_SENSE.n5 VSS 0.28096f
C1253 O_SENSE.t2 VSS 0.29101f
C1254 O_SENSE.t3 VSS 0.29101f
C1255 O_SENSE.n6 VSS 0.97915f
C1256 O_SENSE.n7 VSS 0.28096f
C1257 O_SENSE.t18 VSS 0.29101f
C1258 O_SENSE.t19 VSS 0.29101f
C1259 O_SENSE.n8 VSS 0.97915f
C1260 O_SENSE.n9 VSS 0.28096f
C1261 O_SENSE.t33 VSS 0.29101f
C1262 O_SENSE.t34 VSS 0.29101f
C1263 O_SENSE.n10 VSS 0.97915f
C1264 O_SENSE.n11 VSS 0.28096f
C1265 O_SENSE.t25 VSS 0.29101f
C1266 O_SENSE.t26 VSS 0.29101f
C1267 O_SENSE.n12 VSS 0.97915f
C1268 O_SENSE.n13 VSS 0.28096f
C1269 O_SENSE.t8 VSS 0.29101f
C1270 O_SENSE.t9 VSS 0.29101f
C1271 O_SENSE.n14 VSS 0.97915f
C1272 O_SENSE.n15 VSS 0.28096f
C1273 O_SENSE.t0 VSS 0.29101f
C1274 O_SENSE.t1 VSS 0.29101f
C1275 O_SENSE.n16 VSS 0.97915f
C1276 O_SENSE.n17 VSS 0.28096f
C1277 O_SENSE.t16 VSS 0.29101f
C1278 O_SENSE.t17 VSS 0.29101f
C1279 O_SENSE.n18 VSS 0.97915f
C1280 O_SENSE.n19 VSS 0.28096f
C1281 O_SENSE.t23 VSS 0.29101f
C1282 O_SENSE.t24 VSS 0.29101f
C1283 O_SENSE.n20 VSS 0.97915f
C1284 O_SENSE.n21 VSS 0.28096f
C1285 O_SENSE.t6 VSS 0.29101f
C1286 O_SENSE.t7 VSS 0.29101f
C1287 O_SENSE.n22 VSS 0.97915f
C1288 O_SENSE.n23 VSS 0.28096f
C1289 O_SENSE.t35 VSS 0.29101f
C1290 O_SENSE.t36 VSS 0.29101f
C1291 O_SENSE.n24 VSS 0.97915f
C1292 O_SENSE.n25 VSS 0.28096f
C1293 O_SENSE.t44 VSS 0.29101f
C1294 O_SENSE.t45 VSS 0.29101f
C1295 O_SENSE.n26 VSS 0.97915f
C1296 O_SENSE.n27 VSS 0.28096f
C1297 O_SENSE.t42 VSS 0.29101f
C1298 O_SENSE.t43 VSS 0.29101f
C1299 O_SENSE.n28 VSS 0.97915f
C1300 O_SENSE.n29 VSS 0.28096f
C1301 O_SENSE.t22 VSS 1.30173f
C1302 O_SENSE.n30 VSS 1.58247f
C1303 O_SENSE.t41 VSS 1.30818f
C1304 O_SENSE.t31 VSS 0.29101f
C1305 O_SENSE.t32 VSS 0.29101f
C1306 O_SENSE.n31 VSS 0.97193f
C1307 O_SENSE.n32 VSS 0.54777f
C1308 O_SENSE.t14 VSS 0.29101f
C1309 O_SENSE.t15 VSS 0.29101f
C1310 O_SENSE.n33 VSS 0.97193f
C1311 O_SENSE.n34 VSS 0.28818f
C1312 O_SENSE.t4 VSS 0.29101f
C1313 O_SENSE.t5 VSS 0.29101f
C1314 O_SENSE.n35 VSS 0.97193f
C1315 O_SENSE.n36 VSS 0.28818f
C1316 O_SENSE.t20 VSS 0.29101f
C1317 O_SENSE.t21 VSS 0.29101f
C1318 O_SENSE.n37 VSS 0.97193f
C1319 O_SENSE.n38 VSS 0.28818f
C1320 O_SENSE.t39 VSS 0.29101f
C1321 O_SENSE.t40 VSS 0.29101f
C1322 O_SENSE.n39 VSS 0.97193f
C1323 O_SENSE.n40 VSS 0.28818f
C1324 O_SENSE.t29 VSS 0.29101f
C1325 O_SENSE.t30 VSS 0.29101f
C1326 O_SENSE.n41 VSS 0.97193f
C1327 O_SENSE.n42 VSS 0.28818f
C1328 O_SENSE.t12 VSS 0.29101f
C1329 O_SENSE.t13 VSS 0.29101f
C1330 O_SENSE.n43 VSS 0.97193f
C1331 O_SENSE.n44 VSS 0.28818f
C1332 O_SENSE.t46 VSS 1.29938f
C1333 O_SENSE.n45 VSS 0.85228f
C1334 O_SENSE.n46 VSS 3.00486f
C1335 CLKP_HB.n0 VSS 0.06799f
C1336 CLKP_HB.n1 VSS 0.07393f
C1337 CLKP_HB.n2 VSS 0.07393f
C1338 CLKP_HB.n3 VSS 0.06799f
C1339 CLKP_HB.n4 VSS 0.32453f
C1340 CLKP_HB.n5 VSS 0.06799f
C1341 CLKP_HB.n6 VSS 0.07393f
C1342 CLKP_HB.n7 VSS 0.07393f
C1343 CLKP_HB.n8 VSS 0.06799f
C1344 CLKP_HB.n9 VSS 0.26228f
C1345 CLKP_HB.n10 VSS 0.86518f
C1346 CLKP_HB.n11 VSS 0.06799f
C1347 CLKP_HB.n12 VSS 0.07393f
C1348 CLKP_HB.n13 VSS 0.07393f
C1349 CLKP_HB.n14 VSS 0.06799f
C1350 CLKP_HB.n15 VSS 0.32453f
C1351 CLKP_HB.n16 VSS 0.06799f
C1352 CLKP_HB.n17 VSS 0.07393f
C1353 CLKP_HB.n18 VSS 0.07393f
C1354 CLKP_HB.n19 VSS 0.06799f
C1355 CLKP_HB.n20 VSS 0.26228f
C1356 CLKP_HB.n21 VSS 0.66989f
C1357 CLKP_HB.n22 VSS 1.19189f
C1358 CLKP_H.n0 VSS 0.05975f
C1359 CLKP_H.n1 VSS 0.06497f
C1360 CLKP_H.n2 VSS 0.06497f
C1361 CLKP_H.n3 VSS 0.05975f
C1362 CLKP_H.n4 VSS 0.28519f
C1363 CLKP_H.n5 VSS 0.05975f
C1364 CLKP_H.n6 VSS 0.06497f
C1365 CLKP_H.n7 VSS 0.06497f
C1366 CLKP_H.n8 VSS 0.05975f
C1367 CLKP_H.n9 VSS 0.23049f
C1368 CLKP_H.n10 VSS 1.74315f
C1369 E_CAPTURE_CLKB.t10 VSS 1.05925f
C1370 E_CAPTURE_CLKB.t7 VSS 0.24629f
C1371 E_CAPTURE_CLKB.t6 VSS 0.24629f
C1372 E_CAPTURE_CLKB.n0 VSS 0.78051f
C1373 E_CAPTURE_CLKB.n1 VSS 0.42902f
C1374 E_CAPTURE_CLKB.t1 VSS 0.24629f
C1375 E_CAPTURE_CLKB.t2 VSS 0.24629f
C1376 E_CAPTURE_CLKB.n2 VSS 0.78051f
C1377 E_CAPTURE_CLKB.n3 VSS 0.22396f
C1378 E_CAPTURE_CLKB.t0 VSS 0.24629f
C1379 E_CAPTURE_CLKB.t8 VSS 0.24629f
C1380 E_CAPTURE_CLKB.n4 VSS 0.78051f
C1381 E_CAPTURE_CLKB.n5 VSS 0.22396f
C1382 E_CAPTURE_CLKB.t9 VSS 1.05224f
C1383 E_CAPTURE_CLKB.n6 VSS 0.46336f
C1384 E_CAPTURE_CLKB.t11 VSS 1.05738f
C1385 E_CAPTURE_CLKB.t5 VSS 0.24629f
C1386 E_CAPTURE_CLKB.t15 VSS 0.24629f
C1387 E_CAPTURE_CLKB.n7 VSS 0.77475f
C1388 E_CAPTURE_CLKB.n8 VSS 0.43664f
C1389 E_CAPTURE_CLKB.t4 VSS 0.24629f
C1390 E_CAPTURE_CLKB.t14 VSS 0.24629f
C1391 E_CAPTURE_CLKB.n9 VSS 0.77475f
C1392 E_CAPTURE_CLKB.n10 VSS 0.22971f
C1393 E_CAPTURE_CLKB.t13 VSS 0.24629f
C1394 E_CAPTURE_CLKB.t3 VSS 0.24629f
C1395 E_CAPTURE_CLKB.n11 VSS 0.77475f
C1396 E_CAPTURE_CLKB.n12 VSS 0.22971f
C1397 E_CAPTURE_CLKB.t12 VSS 1.05037f
C1398 E_CAPTURE_CLKB.n13 VSS 0.31419f
C1399 E_CAPTURE_CLKB.n14 VSS 1.0083f
C1400 E_CAPTURE_CLK.t12 VSS 1.02088f
C1401 E_CAPTURE_CLK.t3 VSS 0.24367f
C1402 E_CAPTURE_CLK.t4 VSS 0.24367f
C1403 E_CAPTURE_CLK.n0 VSS 0.74604f
C1404 E_CAPTURE_CLK.n1 VSS 0.41008f
C1405 E_CAPTURE_CLK.t14 VSS 0.24367f
C1406 E_CAPTURE_CLK.t15 VSS 0.24367f
C1407 E_CAPTURE_CLK.n2 VSS 0.74604f
C1408 E_CAPTURE_CLK.n3 VSS 0.21407f
C1409 E_CAPTURE_CLK.t9 VSS 0.24367f
C1410 E_CAPTURE_CLK.t10 VSS 0.24367f
C1411 E_CAPTURE_CLK.n4 VSS 0.74604f
C1412 E_CAPTURE_CLK.n5 VSS 0.21407f
C1413 E_CAPTURE_CLK.t2 VSS 1.01419f
C1414 E_CAPTURE_CLK.n6 VSS 0.4429f
C1415 E_CAPTURE_CLK.t13 VSS 1.0191f
C1416 E_CAPTURE_CLK.t5 VSS 0.24367f
C1417 E_CAPTURE_CLK.t6 VSS 0.24367f
C1418 E_CAPTURE_CLK.n7 VSS 0.74054f
C1419 E_CAPTURE_CLK.n8 VSS 0.41736f
C1420 E_CAPTURE_CLK.t0 VSS 0.24367f
C1421 E_CAPTURE_CLK.t1 VSS 0.24367f
C1422 E_CAPTURE_CLK.n9 VSS 0.74054f
C1423 E_CAPTURE_CLK.n10 VSS 0.21957f
C1424 E_CAPTURE_CLK.t7 VSS 0.24367f
C1425 E_CAPTURE_CLK.t8 VSS 0.24367f
C1426 E_CAPTURE_CLK.n11 VSS 0.74054f
C1427 E_CAPTURE_CLK.n12 VSS 0.21957f
C1428 E_CAPTURE_CLK.t11 VSS 1.0124f
C1429 E_CAPTURE_CLK.n13 VSS 0.30032f
C1430 E_CAPTURE_CLK.n14 VSS 1.53502f
C1431 E_SENSE.t37 VSS 1.31052f
C1432 E_SENSE.t31 VSS 0.29101f
C1433 E_SENSE.t32 VSS 0.29101f
C1434 E_SENSE.n0 VSS 0.97915f
C1435 E_SENSE.n1 VSS 0.53821f
C1436 E_SENSE.t20 VSS 0.29101f
C1437 E_SENSE.t21 VSS 0.29101f
C1438 E_SENSE.n2 VSS 0.97915f
C1439 E_SENSE.n3 VSS 0.28096f
C1440 E_SENSE.t12 VSS 0.29101f
C1441 E_SENSE.t13 VSS 0.29101f
C1442 E_SENSE.n4 VSS 0.97915f
C1443 E_SENSE.n5 VSS 0.28096f
C1444 E_SENSE.t44 VSS 0.29101f
C1445 E_SENSE.t45 VSS 0.29101f
C1446 E_SENSE.n6 VSS 0.97915f
C1447 E_SENSE.n7 VSS 0.28096f
C1448 E_SENSE.t27 VSS 0.29101f
C1449 E_SENSE.t28 VSS 0.29101f
C1450 E_SENSE.n8 VSS 0.97915f
C1451 E_SENSE.n9 VSS 0.28096f
C1452 E_SENSE.t24 VSS 0.29101f
C1453 E_SENSE.t25 VSS 0.29101f
C1454 E_SENSE.n10 VSS 0.97915f
C1455 E_SENSE.n11 VSS 0.28096f
C1456 E_SENSE.t39 VSS 0.29101f
C1457 E_SENSE.t40 VSS 0.29101f
C1458 E_SENSE.n12 VSS 0.97915f
C1459 E_SENSE.n13 VSS 0.28096f
C1460 E_SENSE.t29 VSS 0.29101f
C1461 E_SENSE.t30 VSS 0.29101f
C1462 E_SENSE.n14 VSS 0.97915f
C1463 E_SENSE.n15 VSS 0.28096f
C1464 E_SENSE.t18 VSS 0.29101f
C1465 E_SENSE.t19 VSS 0.29101f
C1466 E_SENSE.n16 VSS 0.97915f
C1467 E_SENSE.n17 VSS 0.28096f
C1468 E_SENSE.t10 VSS 0.29101f
C1469 E_SENSE.t11 VSS 0.29101f
C1470 E_SENSE.n18 VSS 0.97915f
C1471 E_SENSE.n19 VSS 0.28096f
C1472 E_SENSE.t3 VSS 0.29101f
C1473 E_SENSE.t4 VSS 0.29101f
C1474 E_SENSE.n20 VSS 0.97915f
C1475 E_SENSE.n21 VSS 0.28096f
C1476 E_SENSE.t5 VSS 0.29101f
C1477 E_SENSE.t6 VSS 0.29101f
C1478 E_SENSE.n22 VSS 0.97915f
C1479 E_SENSE.n23 VSS 0.28096f
C1480 E_SENSE.t43 VSS 0.29101f
C1481 E_SENSE.t7 VSS 0.29101f
C1482 E_SENSE.n24 VSS 0.97915f
C1483 E_SENSE.n25 VSS 0.28096f
C1484 E_SENSE.t26 VSS 0.29101f
C1485 E_SENSE.t0 VSS 0.29101f
C1486 E_SENSE.n26 VSS 0.97915f
C1487 E_SENSE.n27 VSS 0.28096f
C1488 E_SENSE.t23 VSS 0.29101f
C1489 E_SENSE.t38 VSS 0.29101f
C1490 E_SENSE.n28 VSS 0.97915f
C1491 E_SENSE.n29 VSS 0.28096f
C1492 E_SENSE.t22 VSS 1.30173f
C1493 E_SENSE.n30 VSS 1.58247f
C1494 E_SENSE.t33 VSS 1.30818f
C1495 E_SENSE.t34 VSS 0.29101f
C1496 E_SENSE.t35 VSS 0.29101f
C1497 E_SENSE.n31 VSS 0.97193f
C1498 E_SENSE.n32 VSS 0.54777f
C1499 E_SENSE.t16 VSS 0.29101f
C1500 E_SENSE.t17 VSS 0.29101f
C1501 E_SENSE.n33 VSS 0.97193f
C1502 E_SENSE.n34 VSS 0.28818f
C1503 E_SENSE.t41 VSS 0.29101f
C1504 E_SENSE.t42 VSS 0.29101f
C1505 E_SENSE.n35 VSS 0.97193f
C1506 E_SENSE.n36 VSS 0.28818f
C1507 E_SENSE.t14 VSS 0.29101f
C1508 E_SENSE.t15 VSS 0.29101f
C1509 E_SENSE.n37 VSS 0.97193f
C1510 E_SENSE.n38 VSS 0.28818f
C1511 E_SENSE.t46 VSS 0.29101f
C1512 E_SENSE.t47 VSS 0.29101f
C1513 E_SENSE.n39 VSS 0.97193f
C1514 E_SENSE.n40 VSS 0.28818f
C1515 E_SENSE.t8 VSS 0.29101f
C1516 E_SENSE.t9 VSS 0.29101f
C1517 E_SENSE.n41 VSS 0.97193f
C1518 E_SENSE.n42 VSS 0.28818f
C1519 E_SENSE.t1 VSS 0.29101f
C1520 E_SENSE.t2 VSS 0.29101f
C1521 E_SENSE.n43 VSS 0.97193f
C1522 E_SENSE.n44 VSS 0.28818f
C1523 E_SENSE.t36 VSS 1.29938f
C1524 E_SENSE.n45 VSS 0.85228f
C1525 E_SENSE.n46 VSS 3.00486f
.ends
