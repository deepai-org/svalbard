* PEX produced using /foss/tools/sak/sak-pex.sh with m=3 and s=1 (extresist threshold=0 mOhm, minres=1 mOhm, mindelay=0 ps)
* NGSPICE file created from local_clock_fanout_pex.ext - technology: gf180mcuD

.subckt local_clock_fanout_pex CLKP_H CLKP_HB CLKN_H CLKN_HB VDD VSS E_SENSE E_CAPTURE_CLK
+ E_CAPTURE_CLKB O_SENSE O_CAPTURE_CLK O_CAPTURE_CLKB
X0 VSS.t139 a_2700_41600.t13 O_CAPTURE_CLKB.t10 VSS.t138 nfet_03v3 ad=2.08p pd=8.52u as=2.08p ps=8.52u w=8u l=0.28u
X1 E_CAPTURE_CLKB.t13 a_2700_6400.t8 VSS.t223 VSS.t222 nfet_03v3 ad=3.52p pd=16.88u as=2.08p ps=8.52u w=8u l=0.28u
X2 VDD.t7 a_14540_41600.t79 O_SENSE.t1 VDD.t6 pfet_03v3 ad=2.08p pd=8.52u as=2.08p ps=8.52u w=8u l=0.28u
X3 VDD.t191 a_2700_6400.t17 E_CAPTURE_CLKB.t8 VDD.t190 pfet_03v3 ad=2.08p pd=8.52u as=2.08p ps=8.52u w=8u l=0.28u
X4 VDD.t15 a_14540_6400.t59 E_SENSE.t2 VDD.t14 pfet_03v3 ad=2.08p pd=8.52u as=2.08p ps=8.52u w=8u l=0.28u
X5 VDD.t37 a_2700_41600.t19 O_CAPTURE_CLKB.t1 VDD.t36 pfet_03v3 ad=2.08p pd=8.52u as=2.08p ps=8.52u w=8u l=0.28u
X6 VSS.t175 a_6924_6400.t11 a_14540_6400.t20 VSS.t174 nfet_03v3 ad=2.08p pd=8.52u as=2.08p ps=8.52u w=8u l=0.28u
X7 O_SENSE.t59 a_14540_41600.t64 VDD.t211 VDD.t210 pfet_03v3 ad=2.08p pd=8.52u as=2.08p ps=8.52u w=8u l=0.28u
X8 O_CAPTURE_CLKB.t3 a_2700_41600.t10 VSS.t65 VSS.t64 nfet_03v3 ad=2.08p pd=8.52u as=2.08p ps=8.52u w=8u l=0.28u
X9 a_14540_6400.t0 a_6924_6400.t24 VDD.t1 VDD.t0 pfet_03v3 ad=2.08p pd=8.52u as=2.08p ps=8.52u w=8u l=0.28u
X10 VSS.t219 a_6924_6400.t9 a_14540_6400.t23 VSS.t218 nfet_03v3 ad=2.08p pd=8.52u as=2.08p ps=8.52u w=8u l=0.28u
X11 VSS.t231 CLKP_HB.t1 a_6924_6400.t2 VSS.t230 nfet_03v3 ad=2.08p pd=8.52u as=2.08p ps=8.52u w=8u l=0.28u
X12 a_6924_6400.t5 CLKP_HB.t10 VDD.t237 VDD.t236 pfet_03v3 ad=2.08p pd=8.52u as=2.08p ps=8.52u w=8u l=0.28u
X13 a_14540_6400.t11 a_6924_6400.t22 VDD.t103 VDD.t102 pfet_03v3 ad=2.08p pd=8.52u as=2.08p ps=8.52u w=8u l=0.28u
X14 VSS.t197 a_4812_6400.t15 E_CAPTURE_CLK.t10 VSS.t196 nfet_03v3 ad=2.08p pd=8.52u as=3.52p ps=16.88u w=8u l=0.28u
X15 VDD.t79 a_14540_41600.t73 O_SENSE.t25 VDD.t78 pfet_03v3 ad=2.08p pd=8.52u as=2.08p ps=8.52u w=8u l=0.28u
X16 VSS.t105 a_14540_41600.t55 O_SENSE.t40 VSS.t104 nfet_03v3 ad=2.08p pd=8.52u as=3.52p ps=16.88u w=8u l=0.28u
X17 VDD.t115 a_14540_41600.t85 O_SENSE.t34 VDD.t114 pfet_03v3 ad=2.08p pd=8.52u as=2.08p ps=8.52u w=8u l=0.28u
X18 VSS.t97 a_14540_6400.t53 E_SENSE.t28 VSS.t96 nfet_03v3 ad=2.08p pd=8.52u as=2.08p ps=8.52u w=8u l=0.28u
X19 VSS.t193 a_4812_6400.t13 E_CAPTURE_CLK.t8 VSS.t192 nfet_03v3 ad=2.08p pd=8.52u as=2.08p ps=8.52u w=8u l=0.28u
X20 O_SENSE.t31 a_14540_41600.t40 VSS.t75 VSS.t74 nfet_03v3 ad=2.08p pd=8.52u as=2.08p ps=8.52u w=8u l=0.28u
X21 E_SENSE.t27 a_14540_6400.t86 VDD.t107 VDD.t106 pfet_03v3 ad=2.08p pd=8.52u as=2.08p ps=8.52u w=8u l=0.28u
X22 O_SENSE.t37 a_14540_41600.t70 VDD.t121 VDD.t120 pfet_03v3 ad=2.08p pd=8.52u as=2.08p ps=8.52u w=8u l=0.28u
X23 O_SENSE.t18 a_14540_41600.t52 VSS.t31 VSS.t30 nfet_03v3 ad=2.08p pd=8.52u as=2.08p ps=8.52u w=8u l=0.28u
X24 VDD.t239 CLKP_HB.t11 a_6924_6400.t4 VDD.t238 pfet_03v3 ad=2.08p pd=8.52u as=3.52p ps=16.88u w=8u l=0.28u
X25 VSS.t131 a_14540_6400.t39 E_SENSE.t36 VSS.t130 nfet_03v3 ad=2.08p pd=8.52u as=2.08p ps=8.52u w=8u l=0.28u
X26 O_SENSE.t11 a_14540_41600.t82 VDD.t45 VDD.t44 pfet_03v3 ad=2.08p pd=8.52u as=2.08p ps=8.52u w=8u l=0.28u
X27 E_CAPTURE_CLKB.t1 a_2700_6400.t14 VSS.t21 VSS.t20 nfet_03v3 ad=2.08p pd=8.52u as=2.08p ps=8.52u w=8u l=0.28u
X28 VSS.t7 a_14540_41600.t37 O_SENSE.t7 VSS.t6 nfet_03v3 ad=2.08p pd=8.52u as=2.08p ps=8.52u w=8u l=0.28u
X29 E_CAPTURE_CLK.t9 a_4812_6400.t14 VSS.t195 VSS.t194 nfet_03v3 ad=2.08p pd=8.52u as=2.08p ps=8.52u w=8u l=0.28u
X30 O_SENSE.t9 a_14540_41600.t24 VSS.t11 VSS.t10 nfet_03v3 ad=3.52p pd=16.88u as=2.08p ps=8.52u w=8u l=0.28u
X31 VDD.t63 a_14540_6400.t87 E_SENSE.t18 VDD.t62 pfet_03v3 ad=2.08p pd=8.52u as=3.52p ps=16.88u w=8u l=0.28u
X32 a_14540_41600.t9 a_6924_41600.t16 VSS.t135 VSS.t134 nfet_03v3 ad=2.08p pd=8.52u as=2.08p ps=8.52u w=8u l=0.28u
X33 E_SENSE.t37 a_14540_6400.t40 VSS.t133 VSS.t132 nfet_03v3 ad=2.08p pd=8.52u as=2.08p ps=8.52u w=8u l=0.28u
X34 E_CAPTURE_CLK.t13 a_4812_6400.t8 VSS.t199 VSS.t198 nfet_03v3 ad=3.52p pd=16.88u as=2.08p ps=8.52u w=8u l=0.28u
X35 VDD.t177 a_14540_6400.t81 E_SENSE.t48 VDD.t176 pfet_03v3 ad=2.08p pd=8.52u as=2.08p ps=8.52u w=8u l=0.28u
X36 E_SENSE.t60 a_14540_6400.t46 VSS.t275 VSS.t274 nfet_03v3 ad=2.08p pd=8.52u as=2.08p ps=8.52u w=8u l=0.28u
X37 VSS.t189 a_2700_6400.t15 E_CAPTURE_CLKB.t9 VSS.t188 nfet_03v3 ad=2.08p pd=8.52u as=3.52p ps=16.88u w=8u l=0.28u
X38 a_14540_41600.t22 a_6924_41600.t26 VDD.t281 VDD.t280 pfet_03v3 ad=2.08p pd=8.52u as=2.08p ps=8.52u w=8u l=0.28u
X39 VDD.t147 a_14540_6400.t73 E_SENSE.t40 VDD.t146 pfet_03v3 ad=2.08p pd=8.52u as=2.08p ps=8.52u w=8u l=0.28u
X40 O_CAPTURE_CLKB.t13 a_2700_41600.t16 VDD.t171 VDD.t170 pfet_03v3 ad=3.52p pd=16.88u as=2.08p ps=8.52u w=8u l=0.28u
X41 O_CAPTURE_CLK.t4 a_4812_41600.t14 VSS.t93 VSS.t92 nfet_03v3 ad=2.08p pd=8.52u as=2.08p ps=8.52u w=8u l=0.28u
X42 VSS.t213 a_4812_6400.t9 E_CAPTURE_CLK.t14 VSS.t212 nfet_03v3 ad=2.08p pd=8.52u as=2.08p ps=8.52u w=8u l=0.28u
X43 O_CAPTURE_CLK.t0 a_4812_41600.t20 VDD.t31 VDD.t30 pfet_03v3 ad=2.08p pd=8.52u as=2.08p ps=8.52u w=8u l=0.28u
X44 VDD.t223 a_6924_41600.t23 a_14540_41600.t18 VDD.t222 pfet_03v3 ad=2.08p pd=8.52u as=2.08p ps=8.52u w=8u l=0.28u
X45 O_SENSE.t27 a_14540_41600.t62 VDD.t83 VDD.t82 pfet_03v3 ad=2.08p pd=8.52u as=2.08p ps=8.52u w=8u l=0.28u
X46 E_CAPTURE_CLK.t6 a_4812_6400.t18 VDD.t155 VDD.t154 pfet_03v3 ad=2.08p pd=8.52u as=2.08p ps=8.52u w=8u l=0.28u
X47 E_SENSE.t52 a_14540_6400.t82 VDD.t197 VDD.t196 pfet_03v3 ad=2.08p pd=8.52u as=2.08p ps=8.52u w=8u l=0.28u
X48 VSS.t51 a_14540_6400.t47 E_SENSE.t21 VSS.t50 nfet_03v3 ad=2.08p pd=8.52u as=2.08p ps=8.52u w=8u l=0.28u
X49 a_4812_41600.t1 CLKN_H.t2 VSS.t243 VSS.t242 nfet_03v3 ad=2.08p pd=8.52u as=2.08p ps=8.52u w=8u l=0.28u
X50 E_SENSE.t15 a_14540_6400.t74 VDD.t57 VDD.t56 pfet_03v3 ad=2.08p pd=8.52u as=2.08p ps=8.52u w=8u l=0.28u
X51 VSS.t171 a_4812_41600.t11 O_CAPTURE_CLK.t9 VSS.t170 nfet_03v3 ad=2.08p pd=8.52u as=2.08p ps=8.52u w=8u l=0.28u
X52 E_SENSE.t5 a_14540_6400.t80 VDD.t21 VDD.t20 pfet_03v3 ad=2.08p pd=8.52u as=2.08p ps=8.52u w=8u l=0.28u
X53 a_4812_41600.t7 CLKN_H.t4 VDD.t247 VDD.t246 pfet_03v3 ad=3.52p pd=16.88u as=2.08p ps=8.52u w=8u l=0.28u
X54 VSS.t81 a_14540_6400.t33 E_SENSE.t23 VSS.t80 nfet_03v3 ad=2.08p pd=8.52u as=2.08p ps=8.52u w=8u l=0.28u
X55 E_CAPTURE_CLKB.t12 a_2700_6400.t10 VSS.t221 VSS.t220 nfet_03v3 ad=2.08p pd=8.52u as=2.08p ps=8.52u w=8u l=0.28u
X56 VDD.t287 a_4812_41600.t17 O_CAPTURE_CLK.t15 VDD.t286 pfet_03v3 ad=2.08p pd=8.52u as=2.08p ps=8.52u w=8u l=0.28u
X57 VDD.t11 a_14540_41600.t59 O_SENSE.t3 VDD.t10 pfet_03v3 ad=2.08p pd=8.52u as=2.08p ps=8.52u w=8u l=0.28u
X58 VSS.t255 CLKN_HB.t5 a_2700_41600.t2 VSS.t254 nfet_03v3 ad=2.08p pd=8.52u as=2.08p ps=8.52u w=8u l=0.28u
X59 a_6924_41600.t1 CLKN_HB.t2 VSS.t259 VSS.t258 nfet_03v3 ad=2.08p pd=8.52u as=2.08p ps=8.52u w=8u l=0.28u
X60 VDD.t101 a_2700_6400.t19 E_CAPTURE_CLKB.t4 VDD.t100 pfet_03v3 ad=2.08p pd=8.52u as=2.08p ps=8.52u w=8u l=0.28u
X61 VSS.t57 a_6924_41600.t19 a_14540_41600.t3 VSS.t56 nfet_03v3 ad=2.08p pd=8.52u as=3.52p ps=16.88u w=8u l=0.28u
X62 VDD.t137 a_4812_6400.t19 E_CAPTURE_CLK.t4 VDD.t136 pfet_03v3 ad=2.08p pd=8.52u as=2.08p ps=8.52u w=8u l=0.28u
X63 a_2700_6400.t1 CLKP_HB.t6 VSS.t233 VSS.t232 nfet_03v3 ad=2.08p pd=8.52u as=2.08p ps=8.52u w=8u l=0.28u
X64 E_SENSE.t8 a_14540_6400.t66 VDD.t27 VDD.t26 pfet_03v3 ad=2.08p pd=8.52u as=2.08p ps=8.52u w=8u l=0.28u
X65 a_6924_41600.t7 CLKN_HB.t8 VDD.t249 VDD.t248 pfet_03v3 ad=3.52p pd=16.88u as=2.08p ps=8.52u w=8u l=0.28u
X66 VDD.t131 a_6924_41600.t29 a_14540_41600.t8 VDD.t130 pfet_03v3 ad=2.08p pd=8.52u as=2.08p ps=8.52u w=8u l=0.28u
X67 O_SENSE.t63 a_14540_41600.t68 VDD.t273 VDD.t272 pfet_03v3 ad=2.08p pd=8.52u as=2.08p ps=8.52u w=8u l=0.28u
X68 VDD.t227 CLKP_HB.t15 a_2700_6400.t4 VDD.t226 pfet_03v3 ad=2.08p pd=8.52u as=3.52p ps=16.88u w=8u l=0.28u
X69 a_14540_6400.t5 a_6924_6400.t18 VSS.t25 VSS.t24 nfet_03v3 ad=2.08p pd=8.52u as=2.08p ps=8.52u w=8u l=0.28u
X70 a_2700_6400.t3 CLKP_HB.t4 VSS.t229 VSS.t228 nfet_03v3 ad=3.52p pd=16.88u as=2.08p ps=8.52u w=8u l=0.28u
X71 O_CAPTURE_CLKB.t7 a_2700_41600.t14 VSS.t85 VSS.t84 nfet_03v3 ad=2.08p pd=8.52u as=2.08p ps=8.52u w=8u l=0.28u
X72 O_SENSE.t24 a_14540_41600.t80 VDD.t77 VDD.t76 pfet_03v3 ad=2.08p pd=8.52u as=2.08p ps=8.52u w=8u l=0.28u
X73 VSS.t37 a_14540_41600.t35 O_SENSE.t21 VSS.t36 nfet_03v3 ad=2.08p pd=8.52u as=2.08p ps=8.52u w=8u l=0.28u
X74 VDD.t215 a_14540_6400.t69 E_SENSE.t54 VDD.t214 pfet_03v3 ad=2.08p pd=8.52u as=2.08p ps=8.52u w=8u l=0.28u
X75 E_CAPTURE_CLKB.t5 a_2700_6400.t20 VDD.t109 VDD.t108 pfet_03v3 ad=2.08p pd=8.52u as=2.08p ps=8.52u w=8u l=0.28u
X76 a_4812_6400.t3 CLKP_H.t0 VSS.t271 VSS.t270 nfet_03v3 ad=3.52p pd=16.88u as=2.08p ps=8.52u w=8u l=0.28u
X77 VDD.t59 a_14540_6400.t67 E_SENSE.t16 VDD.t58 pfet_03v3 ad=2.08p pd=8.52u as=2.08p ps=8.52u w=8u l=0.28u
X78 VDD.t85 a_14540_6400.t75 E_SENSE.t25 VDD.t84 pfet_03v3 ad=2.08p pd=8.52u as=2.08p ps=8.52u w=8u l=0.28u
X79 VDD.t195 a_4812_41600.t23 O_CAPTURE_CLK.t11 VDD.t194 pfet_03v3 ad=2.08p pd=8.52u as=3.52p ps=16.88u w=8u l=0.28u
X80 VDD.t123 a_14540_41600.t65 O_SENSE.t38 VDD.t122 pfet_03v3 ad=2.08p pd=8.52u as=2.08p ps=8.52u w=8u l=0.28u
X81 VSS.t69 a_14540_41600.t47 O_SENSE.t28 VSS.t68 nfet_03v3 ad=2.08p pd=8.52u as=2.08p ps=8.52u w=8u l=0.28u
X82 VSS.t23 a_2700_41600.t11 O_CAPTURE_CLKB.t2 VSS.t22 nfet_03v3 ad=2.08p pd=8.52u as=2.08p ps=8.52u w=8u l=0.28u
X83 VSS.t27 a_6924_6400.t19 a_14540_6400.t6 VSS.t26 nfet_03v3 ad=2.08p pd=8.52u as=3.52p ps=16.88u w=8u l=0.28u
X84 VSS.t237 CLKP_HB.t5 a_2700_6400.t2 VSS.t236 nfet_03v3 ad=2.08p pd=8.52u as=2.08p ps=8.52u w=8u l=0.28u
X85 VDD.t119 a_14540_41600.t77 O_SENSE.t36 VDD.t118 pfet_03v3 ad=2.08p pd=8.52u as=2.08p ps=8.52u w=8u l=0.28u
X86 O_SENSE.t54 a_14540_41600.t32 VSS.t179 VSS.t178 nfet_03v3 ad=2.08p pd=8.52u as=2.08p ps=8.52u w=8u l=0.28u
X87 E_SENSE.t51 a_14540_6400.t26 VSS.t187 VSS.t186 nfet_03v3 ad=2.08p pd=8.52u as=2.08p ps=8.52u w=8u l=0.28u
X88 VSS.t265 CLKP_H.t3 a_4812_6400.t0 VSS.t264 nfet_03v3 ad=2.08p pd=8.52u as=3.52p ps=16.88u w=8u l=0.28u
X89 O_SENSE.t10 a_14540_41600.t86 VDD.t43 VDD.t42 pfet_03v3 ad=2.08p pd=8.52u as=2.08p ps=8.52u w=8u l=0.28u
X90 VSS.t269 CLKP_H.t1 a_4812_6400.t2 VSS.t268 nfet_03v3 ad=2.08p pd=8.52u as=2.08p ps=8.52u w=8u l=0.28u
X91 VSS.t111 a_14540_41600.t41 O_SENSE.t44 VSS.t110 nfet_03v3 ad=2.08p pd=8.52u as=2.08p ps=8.52u w=8u l=0.28u
X92 a_4812_6400.t5 CLKP_H.t6 VDD.t267 VDD.t266 pfet_03v3 ad=2.08p pd=8.52u as=2.08p ps=8.52u w=8u l=0.28u
X93 a_2700_41600.t5 CLKN_HB.t14 VDD.t257 VDD.t256 pfet_03v3 ad=2.08p pd=8.52u as=2.08p ps=8.52u w=8u l=0.28u
X94 VDD.t203 a_6924_41600.t21 a_14540_41600.t16 VDD.t202 pfet_03v3 ad=2.08p pd=8.52u as=2.08p ps=8.52u w=8u l=0.28u
X95 VSS.t205 a_14540_41600.t53 O_SENSE.t61 VSS.t204 nfet_03v3 ad=2.08p pd=8.52u as=2.08p ps=8.52u w=8u l=0.28u
X96 VDD.t49 a_14540_41600.t71 O_SENSE.t13 VDD.t48 pfet_03v3 ad=2.08p pd=8.52u as=2.08p ps=8.52u w=8u l=0.28u
X97 VSS.t127 a_14540_6400.t27 E_SENSE.t34 VSS.t126 nfet_03v3 ad=2.08p pd=8.52u as=2.08p ps=8.52u w=8u l=0.28u
X98 VSS.t217 a_2700_6400.t9 E_CAPTURE_CLKB.t11 VSS.t216 nfet_03v3 ad=2.08p pd=8.52u as=2.08p ps=8.52u w=8u l=0.28u
X99 VDD.t5 a_14540_41600.t83 O_SENSE.t0 VDD.t4 pfet_03v3 ad=2.08p pd=8.52u as=2.08p ps=8.52u w=8u l=0.28u
X100 E_SENSE.t3 a_14540_6400.t60 VDD.t17 VDD.t16 pfet_03v3 ad=2.08p pd=8.52u as=2.08p ps=8.52u w=8u l=0.28u
X101 O_SENSE.t8 a_14540_41600.t38 VSS.t9 VSS.t8 nfet_03v3 ad=2.08p pd=8.52u as=2.08p ps=8.52u w=8u l=0.28u
X102 a_14540_6400.t15 a_6924_6400.t12 VSS.t149 VSS.t148 nfet_03v3 ad=2.08p pd=8.52u as=2.08p ps=8.52u w=8u l=0.28u
X103 O_SENSE.t43 a_14540_41600.t50 VSS.t109 VSS.t108 nfet_03v3 ad=2.08p pd=8.52u as=2.08p ps=8.52u w=8u l=0.28u
X104 VDD.t3 a_6924_6400.t25 a_14540_6400.t1 VDD.t2 pfet_03v3 ad=2.08p pd=8.52u as=2.08p ps=8.52u w=8u l=0.28u
X105 a_14540_6400.t19 a_6924_6400.t10 VSS.t173 VSS.t172 nfet_03v3 ad=2.08p pd=8.52u as=2.08p ps=8.52u w=8u l=0.28u
X106 a_6924_6400.t1 CLKP_HB.t2 VSS.t235 VSS.t234 nfet_03v3 ad=2.08p pd=8.52u as=2.08p ps=8.52u w=8u l=0.28u
X107 VDD.t283 a_6924_41600.t27 a_14540_41600.t23 VDD.t282 pfet_03v3 ad=2.08p pd=8.52u as=2.08p ps=8.52u w=8u l=0.28u
X108 VDD.t173 a_2700_41600.t17 O_CAPTURE_CLKB.t14 VDD.t172 pfet_03v3 ad=2.08p pd=8.52u as=2.08p ps=8.52u w=8u l=0.28u
X109 E_SENSE.t29 a_14540_6400.t54 VSS.t99 VSS.t98 nfet_03v3 ad=2.08p pd=8.52u as=2.08p ps=8.52u w=8u l=0.28u
X110 a_14540_41600.t11 a_6924_41600.t14 VSS.t153 VSS.t152 nfet_03v3 ad=2.08p pd=8.52u as=2.08p ps=8.52u w=8u l=0.28u
X111 VDD.t33 a_4812_41600.t21 O_CAPTURE_CLK.t1 VDD.t32 pfet_03v3 ad=2.08p pd=8.52u as=2.08p ps=8.52u w=8u l=0.28u
X112 O_CAPTURE_CLKB.t9 a_2700_41600.t8 VSS.t103 VSS.t102 nfet_03v3 ad=3.52p pd=16.88u as=2.08p ps=8.52u w=8u l=0.28u
X113 a_14540_6400.t21 a_6924_6400.t26 VDD.t183 VDD.t182 pfet_03v3 ad=2.08p pd=8.52u as=2.08p ps=8.52u w=8u l=0.28u
X114 VSS.t225 CLKP_HB.t3 a_6924_6400.t0 VSS.t224 nfet_03v3 ad=2.08p pd=8.52u as=3.52p ps=16.88u w=8u l=0.28u
X115 a_14540_41600.t19 a_6924_41600.t24 VDD.t277 VDD.t276 pfet_03v3 ad=2.08p pd=8.52u as=2.08p ps=8.52u w=8u l=0.28u
X116 O_CAPTURE_CLK.t2 a_4812_41600.t12 VSS.t61 VSS.t60 nfet_03v3 ad=2.08p pd=8.52u as=2.08p ps=8.52u w=8u l=0.28u
X117 VSS.t91 a_6924_41600.t11 a_14540_41600.t6 VSS.t90 nfet_03v3 ad=2.08p pd=8.52u as=2.08p ps=8.52u w=8u l=0.28u
X118 O_SENSE.t57 a_14540_41600.t30 VSS.t183 VSS.t182 nfet_03v3 ad=2.08p pd=8.52u as=2.08p ps=8.52u w=8u l=0.28u
X119 VSS.t49 a_14540_6400.t55 E_SENSE.t19 VSS.t48 nfet_03v3 ad=2.08p pd=8.52u as=3.52p ps=16.88u w=8u l=0.28u
X120 O_CAPTURE_CLK.t6 a_4812_41600.t18 VDD.t111 VDD.t110 pfet_03v3 ad=2.08p pd=8.52u as=2.08p ps=8.52u w=8u l=0.28u
X121 O_SENSE.t4 a_14540_41600.t60 VDD.t13 VDD.t12 pfet_03v3 ad=2.08p pd=8.52u as=2.08p ps=8.52u w=8u l=0.28u
X122 VSS.t119 a_14540_6400.t41 E_SENSE.t30 VSS.t118 nfet_03v3 ad=2.08p pd=8.52u as=2.08p ps=8.52u w=8u l=0.28u
X123 VSS.t283 a_14540_6400.t49 E_SENSE.t62 VSS.t282 nfet_03v3 ad=2.08p pd=8.52u as=2.08p ps=8.52u w=8u l=0.28u
X124 a_2700_41600.t7 CLKN_HB.t12 VDD.t261 VDD.t260 pfet_03v3 ad=3.52p pd=16.88u as=2.08p ps=8.52u w=8u l=0.28u
X125 a_4812_41600.t3 CLKN_H.t0 VSS.t247 VSS.t246 nfet_03v3 ad=3.52p pd=16.88u as=2.08p ps=8.52u w=8u l=0.28u
X126 a_14540_41600.t0 a_6924_41600.t30 VDD.t71 VDD.t70 pfet_03v3 ad=2.08p pd=8.52u as=2.08p ps=8.52u w=8u l=0.28u
X127 VSS.t203 a_4812_41600.t9 O_CAPTURE_CLK.t13 VSS.t202 nfet_03v3 ad=2.08p pd=8.52u as=2.08p ps=8.52u w=8u l=0.28u
X128 VSS.t165 a_14540_41600.t27 O_SENSE.t49 VSS.t164 nfet_03v3 ad=2.08p pd=8.52u as=2.08p ps=8.52u w=8u l=0.28u
X129 VDD.t53 a_14540_41600.t57 O_SENSE.t15 VDD.t52 pfet_03v3 ad=2.08p pd=8.52u as=2.08p ps=8.52u w=8u l=0.28u
X130 a_6924_41600.t3 CLKN_HB.t0 VSS.t253 VSS.t252 nfet_03v3 ad=3.52p pd=16.88u as=2.08p ps=8.52u w=8u l=0.28u
X131 O_SENSE.t22 a_14540_41600.t36 VSS.t39 VSS.t38 nfet_03v3 ad=2.08p pd=8.52u as=2.08p ps=8.52u w=8u l=0.28u
X132 VSS.t137 a_6924_41600.t17 a_14540_41600.t10 VSS.t136 nfet_03v3 ad=2.08p pd=8.52u as=2.08p ps=8.52u w=8u l=0.28u
X133 E_SENSE.t31 a_14540_6400.t42 VSS.t121 VSS.t120 nfet_03v3 ad=2.08p pd=8.52u as=2.08p ps=8.52u w=8u l=0.28u
X134 E_SENSE.t63 a_14540_6400.t50 VSS.t285 VSS.t284 nfet_03v3 ad=2.08p pd=8.52u as=2.08p ps=8.52u w=8u l=0.28u
X135 E_CAPTURE_CLK.t15 a_4812_6400.t10 VSS.t215 VSS.t214 nfet_03v3 ad=2.08p pd=8.52u as=2.08p ps=8.52u w=8u l=0.28u
X136 O_SENSE.t39 a_14540_41600.t66 VDD.t125 VDD.t124 pfet_03v3 ad=2.08p pd=8.52u as=2.08p ps=8.52u w=8u l=0.28u
X137 O_SENSE.t29 a_14540_41600.t48 VSS.t71 VSS.t70 nfet_03v3 ad=2.08p pd=8.52u as=2.08p ps=8.52u w=8u l=0.28u
X138 VDD.t149 a_14540_6400.t83 E_SENSE.t41 VDD.t148 pfet_03v3 ad=2.08p pd=8.52u as=2.08p ps=8.52u w=8u l=0.28u
X139 E_SENSE.t22 a_14540_6400.t48 VSS.t53 VSS.t52 nfet_03v3 ad=2.08p pd=8.52u as=2.08p ps=8.52u w=8u l=0.28u
X140 O_SENSE.t12 a_14540_41600.t78 VDD.t47 VDD.t46 pfet_03v3 ad=2.08p pd=8.52u as=2.08p ps=8.52u w=8u l=0.28u
X141 VSS.t95 a_4812_41600.t15 O_CAPTURE_CLK.t5 VSS.t94 nfet_03v3 ad=2.08p pd=8.52u as=3.52p ps=16.88u w=8u l=0.28u
X142 VSS.t115 a_14540_41600.t33 O_SENSE.t46 VSS.t114 nfet_03v3 ad=2.08p pd=8.52u as=2.08p ps=8.52u w=8u l=0.28u
X143 E_SENSE.t24 a_14540_6400.t34 VSS.t83 VSS.t82 nfet_03v3 ad=2.08p pd=8.52u as=2.08p ps=8.52u w=8u l=0.28u
X144 VSS.t287 a_2700_6400.t11 E_CAPTURE_CLKB.t15 VSS.t286 nfet_03v3 ad=2.08p pd=8.52u as=2.08p ps=8.52u w=8u l=0.28u
X145 VDD.t209 a_14540_41600.t63 O_SENSE.t58 VDD.t208 pfet_03v3 ad=2.08p pd=8.52u as=2.08p ps=8.52u w=8u l=0.28u
X146 VSS.t3 a_14540_41600.t45 O_SENSE.t5 VSS.t2 nfet_03v3 ad=2.08p pd=8.52u as=2.08p ps=8.52u w=8u l=0.28u
X147 VSS.t141 a_4812_6400.t11 E_CAPTURE_CLK.t1 VSS.t140 nfet_03v3 ad=2.08p pd=8.52u as=2.08p ps=8.52u w=8u l=0.28u
X148 E_CAPTURE_CLK.t5 a_4812_6400.t20 VDD.t143 VDD.t142 pfet_03v3 ad=2.08p pd=8.52u as=2.08p ps=8.52u w=8u l=0.28u
X149 E_SENSE.t53 a_14540_6400.t84 VDD.t199 VDD.t198 pfet_03v3 ad=2.08p pd=8.52u as=2.08p ps=8.52u w=8u l=0.28u
X150 VSS.t227 CLKP_HB.t7 a_2700_6400.t0 VSS.t226 nfet_03v3 ad=2.08p pd=8.52u as=3.52p ps=16.88u w=8u l=0.28u
X151 VDD.t259 CLKN_HB.t15 a_2700_41600.t4 VDD.t258 pfet_03v3 ad=2.08p pd=8.52u as=3.52p ps=16.88u w=8u l=0.28u
X152 a_14540_41600.t17 a_6924_41600.t22 VDD.t221 VDD.t220 pfet_03v3 ad=2.08p pd=8.52u as=2.08p ps=8.52u w=8u l=0.28u
X153 VDD.t189 a_14540_41600.t75 O_SENSE.t55 VDD.t188 pfet_03v3 ad=2.08p pd=8.52u as=2.08p ps=8.52u w=8u l=0.28u
X154 O_SENSE.t62 a_14540_41600.t54 VSS.t207 VSS.t206 nfet_03v3 ad=2.08p pd=8.52u as=2.08p ps=8.52u w=8u l=0.28u
X155 VSS.t41 a_14540_6400.t37 E_SENSE.t11 VSS.t40 nfet_03v3 ad=2.08p pd=8.52u as=2.08p ps=8.52u w=8u l=0.28u
X156 VSS.t17 a_14540_6400.t43 E_SENSE.t9 VSS.t16 nfet_03v3 ad=2.08p pd=8.52u as=2.08p ps=8.52u w=8u l=0.28u
X157 VDD.t255 CLKN_HB.t11 a_6924_41600.t4 VDD.t254 pfet_03v3 ad=2.08p pd=8.52u as=3.52p ps=16.88u w=8u l=0.28u
X158 a_2700_41600.t1 CLKN_HB.t6 VSS.t261 VSS.t260 nfet_03v3 ad=2.08p pd=8.52u as=2.08p ps=8.52u w=8u l=0.28u
X159 VSS.t123 a_14540_6400.t35 E_SENSE.t32 VSS.t122 nfet_03v3 ad=2.08p pd=8.52u as=2.08p ps=8.52u w=8u l=0.28u
X160 E_CAPTURE_CLKB.t6 a_2700_6400.t12 VSS.t101 VSS.t100 nfet_03v3 ad=2.08p pd=8.52u as=2.08p ps=8.52u w=8u l=0.28u
X161 E_SENSE.t55 a_14540_6400.t70 VDD.t217 VDD.t216 pfet_03v3 ad=2.08p pd=8.52u as=2.08p ps=8.52u w=8u l=0.28u
X162 VSS.t59 a_6924_41600.t9 a_14540_41600.t4 VSS.t58 nfet_03v3 ad=2.08p pd=8.52u as=2.08p ps=8.52u w=8u l=0.28u
X163 VSS.t73 a_14540_41600.t39 O_SENSE.t30 VSS.t72 nfet_03v3 ad=2.08p pd=8.52u as=2.08p ps=8.52u w=8u l=0.28u
X164 VDD.t29 a_2700_6400.t21 E_CAPTURE_CLKB.t0 VDD.t28 pfet_03v3 ad=2.08p pd=8.52u as=2.08p ps=8.52u w=8u l=0.28u
X165 E_SENSE.t17 a_14540_6400.t68 VDD.t61 VDD.t60 pfet_03v3 ad=2.08p pd=8.52u as=2.08p ps=8.52u w=8u l=0.28u
X166 E_SENSE.t26 a_14540_6400.t76 VDD.t99 VDD.t98 pfet_03v3 ad=2.08p pd=8.52u as=2.08p ps=8.52u w=8u l=0.28u
X167 VSS.t29 a_14540_41600.t51 O_SENSE.t17 VSS.t28 nfet_03v3 ad=2.08p pd=8.52u as=2.08p ps=8.52u w=8u l=0.28u
X168 VDD.t153 a_2700_41600.t23 O_CAPTURE_CLKB.t12 VDD.t152 pfet_03v3 ad=2.08p pd=8.52u as=3.52p ps=16.88u w=8u l=0.28u
X169 VDD.t117 a_14540_41600.t81 O_SENSE.t35 VDD.t116 pfet_03v3 ad=2.08p pd=8.52u as=2.08p ps=8.52u w=8u l=0.28u
X170 a_4812_6400.t1 CLKP_H.t2 VSS.t267 VSS.t266 nfet_03v3 ad=2.08p pd=8.52u as=2.08p ps=8.52u w=8u l=0.28u
X171 VDD.t23 a_14540_6400.t77 E_SENSE.t6 VDD.t22 pfet_03v3 ad=2.08p pd=8.52u as=2.08p ps=8.52u w=8u l=0.28u
X172 O_CAPTURE_CLKB.t5 a_2700_41600.t20 VDD.t87 VDD.t86 pfet_03v3 ad=2.08p pd=8.52u as=2.08p ps=8.52u w=8u l=0.28u
X173 VSS.t155 a_6924_41600.t15 a_14540_41600.t12 VSS.t154 nfet_03v3 ad=2.08p pd=8.52u as=2.08p ps=8.52u w=8u l=0.28u
X174 VSS.t277 a_2700_41600.t9 O_CAPTURE_CLKB.t15 VSS.t276 nfet_03v3 ad=2.08p pd=8.52u as=2.08p ps=8.52u w=8u l=0.28u
X175 VDD.t279 a_6924_41600.t25 a_14540_41600.t20 VDD.t278 pfet_03v3 ad=2.08p pd=8.52u as=2.08p ps=8.52u w=8u l=0.28u
X176 E_SENSE.t35 a_14540_6400.t28 VSS.t129 VSS.t128 nfet_03v3 ad=2.08p pd=8.52u as=2.08p ps=8.52u w=8u l=0.28u
X177 VDD.t167 a_14540_6400.t63 E_SENSE.t46 VDD.t166 pfet_03v3 ad=2.08p pd=8.52u as=2.08p ps=8.52u w=8u l=0.28u
X178 VDD.t163 a_14540_6400.t61 E_SENSE.t44 VDD.t162 pfet_03v3 ad=2.08p pd=8.52u as=2.08p ps=8.52u w=8u l=0.28u
X179 O_SENSE.t48 a_14540_41600.t74 VDD.t145 VDD.t144 pfet_03v3 ad=2.08p pd=8.52u as=2.08p ps=8.52u w=8u l=0.28u
X180 VSS.t63 a_4812_41600.t13 O_CAPTURE_CLK.t3 VSS.t62 nfet_03v3 ad=2.08p pd=8.52u as=2.08p ps=8.52u w=8u l=0.28u
X181 a_14540_41600.t13 a_6924_41600.t12 VSS.t157 VSS.t156 nfet_03v3 ad=2.08p pd=8.52u as=2.08p ps=8.52u w=8u l=0.28u
X182 VSS.t151 a_6924_6400.t13 a_14540_6400.t16 VSS.t150 nfet_03v3 ad=2.08p pd=8.52u as=2.08p ps=8.52u w=8u l=0.28u
X183 VDD.t241 CLKN_H.t7 a_4812_41600.t4 VDD.t240 pfet_03v3 ad=2.08p pd=8.52u as=3.52p ps=16.88u w=8u l=0.28u
X184 VDD.t81 a_14540_41600.t61 O_SENSE.t26 VDD.t80 pfet_03v3 ad=2.08p pd=8.52u as=2.08p ps=8.52u w=8u l=0.28u
X185 E_SENSE.t47 a_14540_6400.t64 VDD.t169 VDD.t168 pfet_03v3 ad=2.08p pd=8.52u as=2.08p ps=8.52u w=8u l=0.28u
X186 O_CAPTURE_CLK.t8 a_4812_41600.t10 VSS.t169 VSS.t168 nfet_03v3 ad=2.08p pd=8.52u as=2.08p ps=8.52u w=8u l=0.28u
X187 O_SENSE.t50 a_14540_41600.t28 VSS.t167 VSS.t166 nfet_03v3 ad=2.08p pd=8.52u as=2.08p ps=8.52u w=8u l=0.28u
X188 E_SENSE.t45 a_14540_6400.t62 VDD.t165 VDD.t164 pfet_03v3 ad=2.08p pd=8.52u as=2.08p ps=8.52u w=8u l=0.28u
X189 O_CAPTURE_CLK.t14 a_4812_41600.t16 VDD.t285 VDD.t284 pfet_03v3 ad=3.52p pd=16.88u as=2.08p ps=8.52u w=8u l=0.28u
X190 O_SENSE.t16 a_14540_41600.t58 VDD.t55 VDD.t54 pfet_03v3 ad=2.08p pd=8.52u as=2.08p ps=8.52u w=8u l=0.28u
X191 a_2700_41600.t3 CLKN_HB.t4 VSS.t249 VSS.t248 nfet_03v3 ad=3.52p pd=16.88u as=2.08p ps=8.52u w=8u l=0.28u
X192 VDD.t41 a_6924_6400.t29 a_14540_6400.t4 VDD.t40 pfet_03v3 ad=2.08p pd=8.52u as=2.08p ps=8.52u w=8u l=0.28u
X193 a_14540_6400.t17 a_6924_6400.t14 VSS.t161 VSS.t160 nfet_03v3 ad=2.08p pd=8.52u as=2.08p ps=8.52u w=8u l=0.28u
X194 E_SENSE.t20 a_14540_6400.t56 VDD.t65 VDD.t64 pfet_03v3 ad=3.52p pd=16.88u as=2.08p ps=8.52u w=8u l=0.28u
X195 a_14540_41600.t2 a_6924_41600.t18 VSS.t55 VSS.t54 nfet_03v3 ad=2.08p pd=8.52u as=2.08p ps=8.52u w=8u l=0.28u
X196 VDD.t185 a_6924_6400.t27 a_14540_6400.t22 VDD.t184 pfet_03v3 ad=2.08p pd=8.52u as=2.08p ps=8.52u w=8u l=0.28u
X197 VSS.t77 a_14540_41600.t25 O_SENSE.t32 VSS.t76 nfet_03v3 ad=2.08p pd=8.52u as=2.08p ps=8.52u w=8u l=0.28u
X198 O_SENSE.t47 a_14540_41600.t34 VSS.t117 VSS.t116 nfet_03v3 ad=2.08p pd=8.52u as=2.08p ps=8.52u w=8u l=0.28u
X199 a_14540_6400.t3 a_6924_6400.t28 VDD.t39 VDD.t38 pfet_03v3 ad=2.08p pd=8.52u as=2.08p ps=8.52u w=8u l=0.28u
X200 VDD.t159 a_14540_6400.t57 E_SENSE.t42 VDD.t158 pfet_03v3 ad=2.08p pd=8.52u as=2.08p ps=8.52u w=8u l=0.28u
X201 O_SENSE.t6 a_14540_41600.t46 VSS.t5 VSS.t4 nfet_03v3 ad=2.08p pd=8.52u as=2.08p ps=8.52u w=8u l=0.28u
X202 O_SENSE.t52 a_14540_41600.t76 VDD.t175 VDD.t174 pfet_03v3 ad=2.08p pd=8.52u as=2.08p ps=8.52u w=8u l=0.28u
X203 VSS.t177 a_14540_41600.t31 O_SENSE.t53 VSS.t176 nfet_03v3 ad=2.08p pd=8.52u as=2.08p ps=8.52u w=8u l=0.28u
X204 a_6924_6400.t7 CLKP_HB.t8 VDD.t235 VDD.t234 pfet_03v3 ad=3.52p pd=16.88u as=2.08p ps=8.52u w=8u l=0.28u
X205 a_14540_6400.t9 a_6924_6400.t20 VDD.t95 VDD.t94 pfet_03v3 ad=3.52p pd=16.88u as=2.08p ps=8.52u w=8u l=0.28u
X206 VSS.t251 CLKN_HB.t7 a_2700_41600.t0 VSS.t250 nfet_03v3 ad=2.08p pd=8.52u as=3.52p ps=16.88u w=8u l=0.28u
X207 a_14540_41600.t5 a_6924_41600.t10 VSS.t89 VSS.t88 nfet_03v3 ad=2.08p pd=8.52u as=2.08p ps=8.52u w=8u l=0.28u
X208 VSS.t33 a_14540_41600.t43 O_SENSE.t19 VSS.t32 nfet_03v3 ad=2.08p pd=8.52u as=2.08p ps=8.52u w=8u l=0.28u
X209 E_CAPTURE_CLKB.t14 a_2700_6400.t16 VDD.t275 VDD.t274 pfet_03v3 ad=3.52p pd=16.88u as=2.08p ps=8.52u w=8u l=0.28u
X210 VDD.t245 CLKN_H.t5 a_4812_41600.t6 VDD.t244 pfet_03v3 ad=2.08p pd=8.52u as=2.08p ps=8.52u w=8u l=0.28u
X211 VSS.t209 a_14540_6400.t51 E_SENSE.t57 VSS.t208 nfet_03v3 ad=2.08p pd=8.52u as=2.08p ps=8.52u w=8u l=0.28u
X212 a_14540_41600.t15 a_6924_41600.t20 VDD.t201 VDD.t200 pfet_03v3 ad=3.52p pd=16.88u as=2.08p ps=8.52u w=8u l=0.28u
X213 VSS.t257 CLKN_HB.t3 a_6924_41600.t0 VSS.t256 nfet_03v3 ad=2.08p pd=8.52u as=3.52p ps=16.88u w=8u l=0.28u
X214 VDD.t105 a_6924_6400.t23 a_14540_6400.t12 VDD.t104 pfet_03v3 ad=2.08p pd=8.52u as=2.08p ps=8.52u w=8u l=0.28u
X215 VDD.t263 CLKN_HB.t9 a_6924_41600.t6 VDD.t262 pfet_03v3 ad=2.08p pd=8.52u as=2.08p ps=8.52u w=8u l=0.28u
X216 VDD.t225 CLKP_HB.t9 a_6924_6400.t6 VDD.t224 pfet_03v3 ad=2.08p pd=8.52u as=2.08p ps=8.52u w=8u l=0.28u
X217 VDD.t97 a_6924_6400.t21 a_14540_6400.t10 VDD.t96 pfet_03v3 ad=2.08p pd=8.52u as=2.08p ps=8.52u w=8u l=0.28u
X218 VSS.t87 a_2700_41600.t15 O_CAPTURE_CLKB.t8 VSS.t86 nfet_03v3 ad=2.08p pd=8.52u as=3.52p ps=16.88u w=8u l=0.28u
X219 VSS.t107 a_14540_41600.t49 O_SENSE.t42 VSS.t106 nfet_03v3 ad=2.08p pd=8.52u as=2.08p ps=8.52u w=8u l=0.28u
X220 VDD.t187 a_4812_6400.t23 E_CAPTURE_CLK.t7 VDD.t186 pfet_03v3 ad=2.08p pd=8.52u as=3.52p ps=16.88u w=8u l=0.28u
X221 E_SENSE.t58 a_14540_6400.t52 VSS.t211 VSS.t210 nfet_03v3 ad=2.08p pd=8.52u as=2.08p ps=8.52u w=8u l=0.28u
X222 E_CAPTURE_CLK.t2 a_4812_6400.t12 VSS.t143 VSS.t142 nfet_03v3 ad=2.08p pd=8.52u as=2.08p ps=8.52u w=8u l=0.28u
X223 VDD.t89 a_2700_41600.t21 O_CAPTURE_CLKB.t6 VDD.t88 pfet_03v3 ad=2.08p pd=8.52u as=2.08p ps=8.52u w=8u l=0.28u
X224 VDD.t135 a_4812_6400.t21 E_CAPTURE_CLK.t3 VDD.t134 pfet_03v3 ad=2.08p pd=8.52u as=2.08p ps=8.52u w=8u l=0.28u
X225 VDD.t179 a_14540_6400.t85 E_SENSE.t49 VDD.t178 pfet_03v3 ad=2.08p pd=8.52u as=2.08p ps=8.52u w=8u l=0.28u
X226 O_CAPTURE_CLKB.t4 a_2700_41600.t12 VSS.t67 VSS.t66 nfet_03v3 ad=2.08p pd=8.52u as=2.08p ps=8.52u w=8u l=0.28u
X227 E_SENSE.t12 a_14540_6400.t38 VSS.t43 VSS.t42 nfet_03v3 ad=2.08p pd=8.52u as=2.08p ps=8.52u w=8u l=0.28u
X228 E_SENSE.t10 a_14540_6400.t44 VSS.t19 VSS.t18 nfet_03v3 ad=2.08p pd=8.52u as=2.08p ps=8.52u w=8u l=0.28u
X229 E_SENSE.t33 a_14540_6400.t36 VSS.t125 VSS.t124 nfet_03v3 ad=2.08p pd=8.52u as=2.08p ps=8.52u w=8u l=0.28u
X230 VSS.t191 a_2700_6400.t13 E_CAPTURE_CLKB.t10 VSS.t190 nfet_03v3 ad=2.08p pd=8.52u as=2.08p ps=8.52u w=8u l=0.28u
X231 VDD.t139 a_14540_6400.t71 E_SENSE.t38 VDD.t138 pfet_03v3 ad=2.08p pd=8.52u as=2.08p ps=8.52u w=8u l=0.28u
X232 O_CAPTURE_CLKB.t0 a_2700_41600.t18 VDD.t35 VDD.t34 pfet_03v3 ad=2.08p pd=8.52u as=2.08p ps=8.52u w=8u l=0.28u
X233 VSS.t159 a_6924_41600.t13 a_14540_41600.t14 VSS.t158 nfet_03v3 ad=2.08p pd=8.52u as=2.08p ps=8.52u w=8u l=0.28u
X234 E_CAPTURE_CLKB.t7 a_2700_6400.t22 VDD.t181 VDD.t180 pfet_03v3 ad=2.08p pd=8.52u as=2.08p ps=8.52u w=8u l=0.28u
X235 VDD.t213 a_14540_41600.t87 O_SENSE.t60 VDD.t212 pfet_03v3 ad=2.08p pd=8.52u as=3.52p ps=16.88u w=8u l=0.28u
X236 E_CAPTURE_CLK.t0 a_4812_6400.t22 VDD.t133 VDD.t132 pfet_03v3 ad=2.08p pd=8.52u as=2.08p ps=8.52u w=8u l=0.28u
X237 O_SENSE.t45 a_14540_41600.t42 VSS.t113 VSS.t112 nfet_03v3 ad=2.08p pd=8.52u as=2.08p ps=8.52u w=8u l=0.28u
X238 VSS.t241 CLKN_H.t3 a_4812_41600.t0 VSS.t240 nfet_03v3 ad=2.08p pd=8.52u as=3.52p ps=16.88u w=8u l=0.28u
X239 E_CAPTURE_CLK.t11 a_4812_6400.t16 VDD.t205 VDD.t204 pfet_03v3 ad=3.52p pd=16.88u as=2.08p ps=8.52u w=8u l=0.28u
X240 VSS.t273 a_14540_6400.t45 E_SENSE.t59 VSS.t272 nfet_03v3 ad=2.08p pd=8.52u as=2.08p ps=8.52u w=8u l=0.28u
X241 O_SENSE.t2 a_14540_41600.t72 VDD.t9 VDD.t8 pfet_03v3 ad=2.08p pd=8.52u as=2.08p ps=8.52u w=8u l=0.28u
X242 VSS.t181 a_14540_41600.t29 O_SENSE.t56 VSS.t180 nfet_03v3 ad=2.08p pd=8.52u as=2.08p ps=8.52u w=8u l=0.28u
X243 E_SENSE.t39 a_14540_6400.t72 VDD.t141 VDD.t140 pfet_03v3 ad=2.08p pd=8.52u as=2.08p ps=8.52u w=8u l=0.28u
X244 O_SENSE.t23 a_14540_41600.t84 VDD.t75 VDD.t74 pfet_03v3 ad=2.08p pd=8.52u as=2.08p ps=8.52u w=8u l=0.28u
X245 VDD.t67 a_2700_6400.t23 E_CAPTURE_CLKB.t2 VDD.t66 pfet_03v3 ad=2.08p pd=8.52u as=3.52p ps=16.88u w=8u l=0.28u
X246 E_SENSE.t4 a_14540_6400.t78 VDD.t19 VDD.t18 pfet_03v3 ad=2.08p pd=8.52u as=2.08p ps=8.52u w=8u l=0.28u
X247 VSS.t13 a_14540_6400.t31 E_SENSE.t0 VSS.t12 nfet_03v3 ad=2.08p pd=8.52u as=2.08p ps=8.52u w=8u l=0.28u
X248 O_CAPTURE_CLK.t12 a_4812_41600.t8 VSS.t201 VSS.t200 nfet_03v3 ad=3.52p pd=16.88u as=2.08p ps=8.52u w=8u l=0.28u
X249 VDD.t157 a_14540_41600.t69 O_SENSE.t51 VDD.t156 pfet_03v3 ad=2.08p pd=8.52u as=2.08p ps=8.52u w=8u l=0.28u
X250 O_SENSE.t33 a_14540_41600.t26 VSS.t79 VSS.t78 nfet_03v3 ad=2.08p pd=8.52u as=2.08p ps=8.52u w=8u l=0.28u
X251 VDD.t207 a_4812_6400.t17 E_CAPTURE_CLK.t12 VDD.t206 pfet_03v3 ad=2.08p pd=8.52u as=2.08p ps=8.52u w=8u l=0.28u
X252 VSS.t45 a_14540_6400.t29 E_SENSE.t13 VSS.t44 nfet_03v3 ad=2.08p pd=8.52u as=2.08p ps=8.52u w=8u l=0.28u
X253 O_SENSE.t41 a_14540_41600.t56 VDD.t127 VDD.t126 pfet_03v3 ad=3.52p pd=16.88u as=2.08p ps=8.52u w=8u l=0.28u
X254 a_14540_41600.t7 a_6924_41600.t28 VDD.t129 VDD.t128 pfet_03v3 ad=2.08p pd=8.52u as=2.08p ps=8.52u w=8u l=0.28u
X255 VDD.t219 a_14540_6400.t79 E_SENSE.t56 VDD.t218 pfet_03v3 ad=2.08p pd=8.52u as=2.08p ps=8.52u w=8u l=0.28u
X256 E_SENSE.t1 a_14540_6400.t32 VSS.t15 VSS.t14 nfet_03v3 ad=2.08p pd=8.52u as=2.08p ps=8.52u w=8u l=0.28u
X257 E_CAPTURE_CLKB.t3 a_2700_6400.t18 VDD.t69 VDD.t68 pfet_03v3 ad=2.08p pd=8.52u as=2.08p ps=8.52u w=8u l=0.28u
X258 E_SENSE.t14 a_14540_6400.t30 VSS.t47 VSS.t46 nfet_03v3 ad=2.08p pd=8.52u as=2.08p ps=8.52u w=8u l=0.28u
X259 VDD.t25 a_14540_6400.t65 E_SENSE.t7 VDD.t24 pfet_03v3 ad=2.08p pd=8.52u as=2.08p ps=8.52u w=8u l=0.28u
X260 O_CAPTURE_CLK.t10 a_4812_41600.t22 VDD.t193 VDD.t192 pfet_03v3 ad=2.08p pd=8.52u as=2.08p ps=8.52u w=8u l=0.28u
X261 a_2700_6400.t5 CLKP_HB.t14 VDD.t229 VDD.t228 pfet_03v3 ad=2.08p pd=8.52u as=2.08p ps=8.52u w=8u l=0.28u
X262 VSS.t147 a_6924_6400.t17 a_14540_6400.t14 VSS.t146 nfet_03v3 ad=2.08p pd=8.52u as=2.08p ps=8.52u w=8u l=0.28u
X263 a_2700_6400.t7 CLKP_HB.t12 VDD.t233 VDD.t232 pfet_03v3 ad=3.52p pd=16.88u as=2.08p ps=8.52u w=8u l=0.28u
X264 a_14540_6400.t7 a_6924_6400.t30 VDD.t91 VDD.t90 pfet_03v3 ad=2.08p pd=8.52u as=2.08p ps=8.52u w=8u l=0.28u
X265 E_SENSE.t61 a_14540_6400.t24 VSS.t279 VSS.t278 nfet_03v3 ad=3.52p pd=16.88u as=2.08p ps=8.52u w=8u l=0.28u
X266 VSS.t163 a_6924_6400.t15 a_14540_6400.t18 VSS.t162 nfet_03v3 ad=2.08p pd=8.52u as=2.08p ps=8.52u w=8u l=0.28u
X267 O_SENSE.t20 a_14540_41600.t44 VSS.t35 VSS.t34 nfet_03v3 ad=2.08p pd=8.52u as=2.08p ps=8.52u w=8u l=0.28u
X268 a_4812_41600.t5 CLKN_H.t6 VDD.t243 VDD.t242 pfet_03v3 ad=2.08p pd=8.52u as=2.08p ps=8.52u w=8u l=0.28u
X269 VDD.t113 a_4812_41600.t19 O_CAPTURE_CLK.t7 VDD.t112 pfet_03v3 ad=2.08p pd=8.52u as=2.08p ps=8.52u w=8u l=0.28u
X270 a_4812_6400.t7 CLKP_H.t4 VDD.t271 VDD.t270 pfet_03v3 ad=3.52p pd=16.88u as=2.08p ps=8.52u w=8u l=0.28u
X271 VSS.t245 CLKN_H.t1 a_4812_41600.t2 VSS.t244 nfet_03v3 ad=2.08p pd=8.52u as=2.08p ps=8.52u w=8u l=0.28u
X272 VDD.t253 CLKN_HB.t13 a_2700_41600.t6 VDD.t252 pfet_03v3 ad=2.08p pd=8.52u as=2.08p ps=8.52u w=8u l=0.28u
X273 a_6924_41600.t5 CLKN_HB.t10 VDD.t251 VDD.t250 pfet_03v3 ad=2.08p pd=8.52u as=2.08p ps=8.52u w=8u l=0.28u
X274 a_14540_41600.t21 a_6924_41600.t8 VSS.t281 VSS.t280 nfet_03v3 ad=3.52p pd=16.88u as=2.08p ps=8.52u w=8u l=0.28u
X275 VDD.t231 CLKP_HB.t13 a_2700_6400.t6 VDD.t230 pfet_03v3 ad=2.08p pd=8.52u as=2.08p ps=8.52u w=8u l=0.28u
X276 VDD.t93 a_6924_6400.t31 a_14540_6400.t8 VDD.t92 pfet_03v3 ad=2.08p pd=8.52u as=3.52p ps=16.88u w=8u l=0.28u
X277 VSS.t185 a_14540_6400.t25 E_SENSE.t50 VSS.t184 nfet_03v3 ad=2.08p pd=8.52u as=2.08p ps=8.52u w=8u l=0.28u
X278 a_14540_6400.t13 a_6924_6400.t16 VSS.t145 VSS.t144 nfet_03v3 ad=2.08p pd=8.52u as=2.08p ps=8.52u w=8u l=0.28u
X279 VDD.t73 a_6924_41600.t31 a_14540_41600.t1 VDD.t72 pfet_03v3 ad=2.08p pd=8.52u as=3.52p ps=16.88u w=8u l=0.28u
X280 E_SENSE.t43 a_14540_6400.t58 VDD.t161 VDD.t160 pfet_03v3 ad=2.08p pd=8.52u as=2.08p ps=8.52u w=8u l=0.28u
X281 VSS.t263 CLKN_HB.t1 a_6924_41600.t2 VSS.t262 nfet_03v3 ad=2.08p pd=8.52u as=2.08p ps=8.52u w=8u l=0.28u
X282 VDD.t265 CLKP_H.t7 a_4812_6400.t4 VDD.t264 pfet_03v3 ad=2.08p pd=8.52u as=3.52p ps=16.88u w=8u l=0.28u
X283 O_CAPTURE_CLKB.t11 a_2700_41600.t22 VDD.t151 VDD.t150 pfet_03v3 ad=2.08p pd=8.52u as=2.08p ps=8.52u w=8u l=0.28u
X284 VDD.t269 CLKP_H.t5 a_4812_6400.t6 VDD.t268 pfet_03v3 ad=2.08p pd=8.52u as=2.08p ps=8.52u w=8u l=0.28u
X285 VDD.t51 a_14540_41600.t67 O_SENSE.t14 VDD.t50 pfet_03v3 ad=2.08p pd=8.52u as=2.08p ps=8.52u w=8u l=0.28u
X286 a_14540_6400.t2 a_6924_6400.t8 VSS.t1 VSS.t0 nfet_03v3 ad=3.52p pd=16.88u as=2.08p ps=8.52u w=8u l=0.28u
X287 a_6924_6400.t3 CLKP_HB.t0 VSS.t239 VSS.t238 nfet_03v3 ad=3.52p pd=16.88u as=2.08p ps=8.52u w=8u l=0.28u
R0 E_SENSE E_SENSE.n62 11.7381
R1 E_SENSE.n62 E_SENSE.n30 6.5392
R2 E_SENSE.n32 E_SENSE.t61 5.7796
R3 E_SENSE.n1 E_SENSE.t20 5.73764
R4 E_SENSE.n61 E_SENSE.t19 5.59012
R5 E_SENSE.n30 E_SENSE.t18 5.54817
R6 E_SENSE.n32 E_SENSE.n31 5.38537
R7 E_SENSE.n34 E_SENSE.n33 5.38537
R8 E_SENSE.n36 E_SENSE.n35 5.38537
R9 E_SENSE.n38 E_SENSE.n37 5.38537
R10 E_SENSE.n40 E_SENSE.n39 5.38537
R11 E_SENSE.n42 E_SENSE.n41 5.38537
R12 E_SENSE.n44 E_SENSE.n43 5.38537
R13 E_SENSE.n46 E_SENSE.n45 5.38537
R14 E_SENSE.n48 E_SENSE.n47 5.38537
R15 E_SENSE.n50 E_SENSE.n49 5.38537
R16 E_SENSE.n52 E_SENSE.n51 5.38537
R17 E_SENSE.n54 E_SENSE.n53 5.38537
R18 E_SENSE.n56 E_SENSE.n55 5.38537
R19 E_SENSE.n58 E_SENSE.n57 5.38537
R20 E_SENSE.n60 E_SENSE.n59 5.38537
R21 E_SENSE.n1 E_SENSE.n0 5.32067
R22 E_SENSE.n3 E_SENSE.n2 5.32067
R23 E_SENSE.n5 E_SENSE.n4 5.32067
R24 E_SENSE.n7 E_SENSE.n6 5.32067
R25 E_SENSE.n9 E_SENSE.n8 5.32067
R26 E_SENSE.n11 E_SENSE.n10 5.32067
R27 E_SENSE.n13 E_SENSE.n12 5.32067
R28 E_SENSE.n15 E_SENSE.n14 5.32067
R29 E_SENSE.n17 E_SENSE.n16 5.32067
R30 E_SENSE.n19 E_SENSE.n18 5.32067
R31 E_SENSE.n21 E_SENSE.n20 5.32067
R32 E_SENSE.n23 E_SENSE.n22 5.32067
R33 E_SENSE.n25 E_SENSE.n24 5.32067
R34 E_SENSE.n27 E_SENSE.n26 5.32067
R35 E_SENSE.n29 E_SENSE.n28 5.32067
R36 E_SENSE.n62 E_SENSE.n61 4.61063
R37 E_SENSE.n0 E_SENSE.t43 0.228
R38 E_SENSE.n0 E_SENSE.t42 0.228
R39 E_SENSE.n2 E_SENSE.t3 0.228
R40 E_SENSE.n2 E_SENSE.t2 0.228
R41 E_SENSE.n4 E_SENSE.t45 0.228
R42 E_SENSE.n4 E_SENSE.t44 0.228
R43 E_SENSE.n6 E_SENSE.t47 0.228
R44 E_SENSE.n6 E_SENSE.t46 0.228
R45 E_SENSE.n8 E_SENSE.t8 0.228
R46 E_SENSE.n8 E_SENSE.t7 0.228
R47 E_SENSE.n10 E_SENSE.t17 0.228
R48 E_SENSE.n10 E_SENSE.t16 0.228
R49 E_SENSE.n12 E_SENSE.t55 0.228
R50 E_SENSE.n12 E_SENSE.t54 0.228
R51 E_SENSE.n14 E_SENSE.t39 0.228
R52 E_SENSE.n14 E_SENSE.t38 0.228
R53 E_SENSE.n16 E_SENSE.t15 0.228
R54 E_SENSE.n16 E_SENSE.t40 0.228
R55 E_SENSE.n18 E_SENSE.t26 0.228
R56 E_SENSE.n18 E_SENSE.t25 0.228
R57 E_SENSE.n20 E_SENSE.t4 0.228
R58 E_SENSE.n20 E_SENSE.t6 0.228
R59 E_SENSE.n22 E_SENSE.t5 0.228
R60 E_SENSE.n22 E_SENSE.t56 0.228
R61 E_SENSE.n24 E_SENSE.t52 0.228
R62 E_SENSE.n24 E_SENSE.t48 0.228
R63 E_SENSE.n26 E_SENSE.t53 0.228
R64 E_SENSE.n26 E_SENSE.t41 0.228
R65 E_SENSE.n28 E_SENSE.t27 0.228
R66 E_SENSE.n28 E_SENSE.t49 0.228
R67 E_SENSE.n31 E_SENSE.t51 0.20525
R68 E_SENSE.n31 E_SENSE.t50 0.20525
R69 E_SENSE.n33 E_SENSE.t35 0.20525
R70 E_SENSE.n33 E_SENSE.t34 0.20525
R71 E_SENSE.n35 E_SENSE.t14 0.20525
R72 E_SENSE.n35 E_SENSE.t13 0.20525
R73 E_SENSE.n37 E_SENSE.t1 0.20525
R74 E_SENSE.n37 E_SENSE.t0 0.20525
R75 E_SENSE.n39 E_SENSE.t24 0.20525
R76 E_SENSE.n39 E_SENSE.t23 0.20525
R77 E_SENSE.n41 E_SENSE.t33 0.20525
R78 E_SENSE.n41 E_SENSE.t32 0.20525
R79 E_SENSE.n43 E_SENSE.t12 0.20525
R80 E_SENSE.n43 E_SENSE.t11 0.20525
R81 E_SENSE.n45 E_SENSE.t37 0.20525
R82 E_SENSE.n45 E_SENSE.t36 0.20525
R83 E_SENSE.n47 E_SENSE.t31 0.20525
R84 E_SENSE.n47 E_SENSE.t30 0.20525
R85 E_SENSE.n49 E_SENSE.t10 0.20525
R86 E_SENSE.n49 E_SENSE.t9 0.20525
R87 E_SENSE.n51 E_SENSE.t60 0.20525
R88 E_SENSE.n51 E_SENSE.t59 0.20525
R89 E_SENSE.n53 E_SENSE.t22 0.20525
R90 E_SENSE.n53 E_SENSE.t21 0.20525
R91 E_SENSE.n55 E_SENSE.t63 0.20525
R92 E_SENSE.n55 E_SENSE.t62 0.20525
R93 E_SENSE.n57 E_SENSE.t58 0.20525
R94 E_SENSE.n57 E_SENSE.t57 0.20525
R95 E_SENSE.n59 E_SENSE.t29 0.20525
R96 E_SENSE.n59 E_SENSE.t28 0.20525
R97 E_SENSE.n61 E_SENSE.n60 0.189974
R98 E_SENSE.n60 E_SENSE.n58 0.189974
R99 E_SENSE.n58 E_SENSE.n56 0.189974
R100 E_SENSE.n56 E_SENSE.n54 0.189974
R101 E_SENSE.n54 E_SENSE.n52 0.189974
R102 E_SENSE.n52 E_SENSE.n50 0.189974
R103 E_SENSE.n50 E_SENSE.n48 0.189974
R104 E_SENSE.n48 E_SENSE.n46 0.189974
R105 E_SENSE.n46 E_SENSE.n44 0.189974
R106 E_SENSE.n44 E_SENSE.n42 0.189974
R107 E_SENSE.n42 E_SENSE.n40 0.189974
R108 E_SENSE.n40 E_SENSE.n38 0.189974
R109 E_SENSE.n38 E_SENSE.n36 0.189974
R110 E_SENSE.n36 E_SENSE.n34 0.189974
R111 E_SENSE.n34 E_SENSE.n32 0.189974
R112 E_SENSE.n30 E_SENSE.n29 0.189974
R113 E_SENSE.n29 E_SENSE.n27 0.189974
R114 E_SENSE.n27 E_SENSE.n25 0.189974
R115 E_SENSE.n25 E_SENSE.n23 0.189974
R116 E_SENSE.n23 E_SENSE.n21 0.189974
R117 E_SENSE.n21 E_SENSE.n19 0.189974
R118 E_SENSE.n19 E_SENSE.n17 0.189974
R119 E_SENSE.n17 E_SENSE.n15 0.189974
R120 E_SENSE.n15 E_SENSE.n13 0.189974
R121 E_SENSE.n13 E_SENSE.n11 0.189974
R122 E_SENSE.n11 E_SENSE.n9 0.189974
R123 E_SENSE.n9 E_SENSE.n7 0.189974
R124 E_SENSE.n7 E_SENSE.n5 0.189974
R125 E_SENSE.n5 E_SENSE.n3 0.189974
R126 E_SENSE.n3 E_SENSE.n1 0.189974
R127 E_CAPTURE_CLK E_CAPTURE_CLK.n14 7.98157
R128 E_CAPTURE_CLK.n14 E_CAPTURE_CLK.n6 6.5392
R129 E_CAPTURE_CLK.n8 E_CAPTURE_CLK.t13 5.7796
R130 E_CAPTURE_CLK.n1 E_CAPTURE_CLK.t11 5.73764
R131 E_CAPTURE_CLK.n13 E_CAPTURE_CLK.t10 5.59012
R132 E_CAPTURE_CLK.n6 E_CAPTURE_CLK.t7 5.54817
R133 E_CAPTURE_CLK.n8 E_CAPTURE_CLK.n7 5.38537
R134 E_CAPTURE_CLK.n10 E_CAPTURE_CLK.n9 5.38537
R135 E_CAPTURE_CLK.n12 E_CAPTURE_CLK.n11 5.38537
R136 E_CAPTURE_CLK.n1 E_CAPTURE_CLK.n0 5.32067
R137 E_CAPTURE_CLK.n3 E_CAPTURE_CLK.n2 5.32067
R138 E_CAPTURE_CLK.n5 E_CAPTURE_CLK.n4 5.32067
R139 E_CAPTURE_CLK.n14 E_CAPTURE_CLK.n13 4.61063
R140 E_CAPTURE_CLK.n0 E_CAPTURE_CLK.t6 0.228
R141 E_CAPTURE_CLK.n0 E_CAPTURE_CLK.t12 0.228
R142 E_CAPTURE_CLK.n2 E_CAPTURE_CLK.t5 0.228
R143 E_CAPTURE_CLK.n2 E_CAPTURE_CLK.t4 0.228
R144 E_CAPTURE_CLK.n4 E_CAPTURE_CLK.t0 0.228
R145 E_CAPTURE_CLK.n4 E_CAPTURE_CLK.t3 0.228
R146 E_CAPTURE_CLK.n7 E_CAPTURE_CLK.t15 0.20525
R147 E_CAPTURE_CLK.n7 E_CAPTURE_CLK.t14 0.20525
R148 E_CAPTURE_CLK.n9 E_CAPTURE_CLK.t2 0.20525
R149 E_CAPTURE_CLK.n9 E_CAPTURE_CLK.t1 0.20525
R150 E_CAPTURE_CLK.n11 E_CAPTURE_CLK.t9 0.20525
R151 E_CAPTURE_CLK.n11 E_CAPTURE_CLK.t8 0.20525
R152 E_CAPTURE_CLK.n13 E_CAPTURE_CLK.n12 0.189974
R153 E_CAPTURE_CLK.n12 E_CAPTURE_CLK.n10 0.189974
R154 E_CAPTURE_CLK.n10 E_CAPTURE_CLK.n8 0.189974
R155 E_CAPTURE_CLK.n6 E_CAPTURE_CLK.n5 0.189974
R156 E_CAPTURE_CLK.n5 E_CAPTURE_CLK.n3 0.189974
R157 E_CAPTURE_CLK.n3 E_CAPTURE_CLK.n1 0.189974
R158 E_CAPTURE_CLKB E_CAPTURE_CLKB.n14 6.63157
R159 E_CAPTURE_CLKB.n14 E_CAPTURE_CLKB.n6 6.5392
R160 E_CAPTURE_CLKB.n8 E_CAPTURE_CLKB.t13 5.7796
R161 E_CAPTURE_CLKB.n1 E_CAPTURE_CLKB.t14 5.73764
R162 E_CAPTURE_CLKB.n13 E_CAPTURE_CLKB.t9 5.59012
R163 E_CAPTURE_CLKB.n6 E_CAPTURE_CLKB.t2 5.54817
R164 E_CAPTURE_CLKB.n8 E_CAPTURE_CLKB.n7 5.38537
R165 E_CAPTURE_CLKB.n10 E_CAPTURE_CLKB.n9 5.38537
R166 E_CAPTURE_CLKB.n12 E_CAPTURE_CLKB.n11 5.38537
R167 E_CAPTURE_CLKB.n1 E_CAPTURE_CLKB.n0 5.32067
R168 E_CAPTURE_CLKB.n3 E_CAPTURE_CLKB.n2 5.32067
R169 E_CAPTURE_CLKB.n5 E_CAPTURE_CLKB.n4 5.32067
R170 E_CAPTURE_CLKB.n14 E_CAPTURE_CLKB.n13 4.61063
R171 E_CAPTURE_CLKB.n0 E_CAPTURE_CLKB.t3 0.228
R172 E_CAPTURE_CLKB.n0 E_CAPTURE_CLKB.t8 0.228
R173 E_CAPTURE_CLKB.n2 E_CAPTURE_CLKB.t5 0.228
R174 E_CAPTURE_CLKB.n2 E_CAPTURE_CLKB.t4 0.228
R175 E_CAPTURE_CLKB.n4 E_CAPTURE_CLKB.t7 0.228
R176 E_CAPTURE_CLKB.n4 E_CAPTURE_CLKB.t0 0.228
R177 E_CAPTURE_CLKB.n7 E_CAPTURE_CLKB.t12 0.20525
R178 E_CAPTURE_CLKB.n7 E_CAPTURE_CLKB.t11 0.20525
R179 E_CAPTURE_CLKB.n9 E_CAPTURE_CLKB.t6 0.20525
R180 E_CAPTURE_CLKB.n9 E_CAPTURE_CLKB.t15 0.20525
R181 E_CAPTURE_CLKB.n11 E_CAPTURE_CLKB.t1 0.20525
R182 E_CAPTURE_CLKB.n11 E_CAPTURE_CLKB.t10 0.20525
R183 E_CAPTURE_CLKB.n13 E_CAPTURE_CLKB.n12 0.189974
R184 E_CAPTURE_CLKB.n12 E_CAPTURE_CLKB.n10 0.189974
R185 E_CAPTURE_CLKB.n10 E_CAPTURE_CLKB.n8 0.189974
R186 E_CAPTURE_CLKB.n6 E_CAPTURE_CLKB.n5 0.189974
R187 E_CAPTURE_CLKB.n5 E_CAPTURE_CLKB.n3 0.189974
R188 E_CAPTURE_CLKB.n3 E_CAPTURE_CLKB.n1 0.189974
R189 CLKP_H.n8 CLKP_H.t3 113.632
R190 CLKP_H.n5 CLKP_H.t0 113.632
R191 CLKP_H.n0 CLKP_H.t4 113.632
R192 CLKP_H.n3 CLKP_H.t7 113.632
R193 CLKP_H.n6 CLKP_H.t1 109.174
R194 CLKP_H.n7 CLKP_H.t2 109.174
R195 CLKP_H.n1 CLKP_H.t5 109.174
R196 CLKP_H.n2 CLKP_H.t6 109.174
R197 CLKP_H CLKP_H.n10 15.3874
R198 CLKP_H.n7 CLKP_H.n6 11.6805
R199 CLKP_H.n2 CLKP_H.n1 11.6805
R200 CLKP_H.n10 CLKP_H.n4 10.9291
R201 CLKP_H.n10 CLKP_H.n9 9.0005
R202 CLKP_H.n9 CLKP_H.n5 7.10487
R203 CLKP_H.n9 CLKP_H.n8 7.10487
R204 CLKP_H.n4 CLKP_H.n0 7.10487
R205 CLKP_H.n4 CLKP_H.n3 7.10487
R206 CLKP_H.n6 CLKP_H.n5 4.42851
R207 CLKP_H.n8 CLKP_H.n7 4.42851
R208 CLKP_H.n1 CLKP_H.n0 4.42851
R209 CLKP_H.n3 CLKP_H.n2 4.42851
R210 CLKP_HB.n8 CLKP_HB.t3 113.632
R211 CLKP_HB.n5 CLKP_HB.t0 113.632
R212 CLKP_HB.n3 CLKP_HB.t11 113.632
R213 CLKP_HB.n0 CLKP_HB.t8 113.632
R214 CLKP_HB.n19 CLKP_HB.t7 113.632
R215 CLKP_HB.n16 CLKP_HB.t4 113.632
R216 CLKP_HB.n11 CLKP_HB.t12 113.632
R217 CLKP_HB.n14 CLKP_HB.t15 113.632
R218 CLKP_HB.n6 CLKP_HB.t1 109.174
R219 CLKP_HB.n7 CLKP_HB.t2 109.174
R220 CLKP_HB.n1 CLKP_HB.t9 109.174
R221 CLKP_HB.n2 CLKP_HB.t10 109.174
R222 CLKP_HB.n17 CLKP_HB.t5 109.174
R223 CLKP_HB.n18 CLKP_HB.t6 109.174
R224 CLKP_HB.n12 CLKP_HB.t13 109.174
R225 CLKP_HB.n13 CLKP_HB.t14 109.174
R226 CLKP_HB.n7 CLKP_HB.n6 11.6805
R227 CLKP_HB.n2 CLKP_HB.n1 11.6805
R228 CLKP_HB.n18 CLKP_HB.n17 11.6805
R229 CLKP_HB.n13 CLKP_HB.n12 11.6805
R230 CLKP_HB.n10 CLKP_HB.n4 10.9291
R231 CLKP_HB.n21 CLKP_HB.n15 10.9291
R232 CLKP_HB.n10 CLKP_HB.n9 9.0005
R233 CLKP_HB.n21 CLKP_HB.n20 9.0005
R234 CLKP_HB.n22 CLKP_HB.n10 8.70954
R235 CLKP_HB CLKP_HB.n22 8.25354
R236 CLKP_HB.n9 CLKP_HB.n5 7.10487
R237 CLKP_HB.n9 CLKP_HB.n8 7.10487
R238 CLKP_HB.n4 CLKP_HB.n0 7.10487
R239 CLKP_HB.n4 CLKP_HB.n3 7.10487
R240 CLKP_HB.n20 CLKP_HB.n16 7.10487
R241 CLKP_HB.n20 CLKP_HB.n19 7.10487
R242 CLKP_HB.n15 CLKP_HB.n11 7.10487
R243 CLKP_HB.n15 CLKP_HB.n14 7.10487
R244 CLKP_HB.n22 CLKP_HB.n21 4.59693
R245 CLKP_HB.n6 CLKP_HB.n5 4.42851
R246 CLKP_HB.n8 CLKP_HB.n7 4.42851
R247 CLKP_HB.n1 CLKP_HB.n0 4.42851
R248 CLKP_HB.n3 CLKP_HB.n2 4.42851
R249 CLKP_HB.n17 CLKP_HB.n16 4.42851
R250 CLKP_HB.n19 CLKP_HB.n18 4.42851
R251 CLKP_HB.n12 CLKP_HB.n11 4.42851
R252 CLKP_HB.n14 CLKP_HB.n13 4.42851
R253 O_SENSE O_SENSE.n62 11.7381
R254 O_SENSE.n62 O_SENSE.n30 6.5392
R255 O_SENSE.n32 O_SENSE.t9 5.7796
R256 O_SENSE.n1 O_SENSE.t41 5.73764
R257 O_SENSE.n61 O_SENSE.t40 5.59012
R258 O_SENSE.n30 O_SENSE.t60 5.54817
R259 O_SENSE.n32 O_SENSE.n31 5.38537
R260 O_SENSE.n34 O_SENSE.n33 5.38537
R261 O_SENSE.n36 O_SENSE.n35 5.38537
R262 O_SENSE.n38 O_SENSE.n37 5.38537
R263 O_SENSE.n40 O_SENSE.n39 5.38537
R264 O_SENSE.n42 O_SENSE.n41 5.38537
R265 O_SENSE.n44 O_SENSE.n43 5.38537
R266 O_SENSE.n46 O_SENSE.n45 5.38537
R267 O_SENSE.n48 O_SENSE.n47 5.38537
R268 O_SENSE.n50 O_SENSE.n49 5.38537
R269 O_SENSE.n52 O_SENSE.n51 5.38537
R270 O_SENSE.n54 O_SENSE.n53 5.38537
R271 O_SENSE.n56 O_SENSE.n55 5.38537
R272 O_SENSE.n58 O_SENSE.n57 5.38537
R273 O_SENSE.n60 O_SENSE.n59 5.38537
R274 O_SENSE.n1 O_SENSE.n0 5.32067
R275 O_SENSE.n3 O_SENSE.n2 5.32067
R276 O_SENSE.n5 O_SENSE.n4 5.32067
R277 O_SENSE.n7 O_SENSE.n6 5.32067
R278 O_SENSE.n9 O_SENSE.n8 5.32067
R279 O_SENSE.n11 O_SENSE.n10 5.32067
R280 O_SENSE.n13 O_SENSE.n12 5.32067
R281 O_SENSE.n15 O_SENSE.n14 5.32067
R282 O_SENSE.n17 O_SENSE.n16 5.32067
R283 O_SENSE.n19 O_SENSE.n18 5.32067
R284 O_SENSE.n21 O_SENSE.n20 5.32067
R285 O_SENSE.n23 O_SENSE.n22 5.32067
R286 O_SENSE.n25 O_SENSE.n24 5.32067
R287 O_SENSE.n27 O_SENSE.n26 5.32067
R288 O_SENSE.n29 O_SENSE.n28 5.32067
R289 O_SENSE.n62 O_SENSE.n61 4.61063
R290 O_SENSE.n0 O_SENSE.t16 0.228
R291 O_SENSE.n0 O_SENSE.t15 0.228
R292 O_SENSE.n2 O_SENSE.t4 0.228
R293 O_SENSE.n2 O_SENSE.t3 0.228
R294 O_SENSE.n4 O_SENSE.t27 0.228
R295 O_SENSE.n4 O_SENSE.t26 0.228
R296 O_SENSE.n6 O_SENSE.t59 0.228
R297 O_SENSE.n6 O_SENSE.t58 0.228
R298 O_SENSE.n8 O_SENSE.t39 0.228
R299 O_SENSE.n8 O_SENSE.t38 0.228
R300 O_SENSE.n10 O_SENSE.t63 0.228
R301 O_SENSE.n10 O_SENSE.t14 0.228
R302 O_SENSE.n12 O_SENSE.t37 0.228
R303 O_SENSE.n12 O_SENSE.t51 0.228
R304 O_SENSE.n14 O_SENSE.t2 0.228
R305 O_SENSE.n14 O_SENSE.t13 0.228
R306 O_SENSE.n16 O_SENSE.t48 0.228
R307 O_SENSE.n16 O_SENSE.t25 0.228
R308 O_SENSE.n18 O_SENSE.t52 0.228
R309 O_SENSE.n18 O_SENSE.t55 0.228
R310 O_SENSE.n20 O_SENSE.t12 0.228
R311 O_SENSE.n20 O_SENSE.t36 0.228
R312 O_SENSE.n22 O_SENSE.t24 0.228
R313 O_SENSE.n22 O_SENSE.t1 0.228
R314 O_SENSE.n24 O_SENSE.t11 0.228
R315 O_SENSE.n24 O_SENSE.t35 0.228
R316 O_SENSE.n26 O_SENSE.t23 0.228
R317 O_SENSE.n26 O_SENSE.t0 0.228
R318 O_SENSE.n28 O_SENSE.t10 0.228
R319 O_SENSE.n28 O_SENSE.t34 0.228
R320 O_SENSE.n31 O_SENSE.t33 0.20525
R321 O_SENSE.n31 O_SENSE.t32 0.20525
R322 O_SENSE.n33 O_SENSE.t50 0.20525
R323 O_SENSE.n33 O_SENSE.t49 0.20525
R324 O_SENSE.n35 O_SENSE.t57 0.20525
R325 O_SENSE.n35 O_SENSE.t56 0.20525
R326 O_SENSE.n37 O_SENSE.t54 0.20525
R327 O_SENSE.n37 O_SENSE.t53 0.20525
R328 O_SENSE.n39 O_SENSE.t47 0.20525
R329 O_SENSE.n39 O_SENSE.t46 0.20525
R330 O_SENSE.n41 O_SENSE.t22 0.20525
R331 O_SENSE.n41 O_SENSE.t21 0.20525
R332 O_SENSE.n43 O_SENSE.t8 0.20525
R333 O_SENSE.n43 O_SENSE.t7 0.20525
R334 O_SENSE.n45 O_SENSE.t31 0.20525
R335 O_SENSE.n45 O_SENSE.t30 0.20525
R336 O_SENSE.n47 O_SENSE.t45 0.20525
R337 O_SENSE.n47 O_SENSE.t44 0.20525
R338 O_SENSE.n49 O_SENSE.t20 0.20525
R339 O_SENSE.n49 O_SENSE.t19 0.20525
R340 O_SENSE.n51 O_SENSE.t6 0.20525
R341 O_SENSE.n51 O_SENSE.t5 0.20525
R342 O_SENSE.n53 O_SENSE.t29 0.20525
R343 O_SENSE.n53 O_SENSE.t28 0.20525
R344 O_SENSE.n55 O_SENSE.t43 0.20525
R345 O_SENSE.n55 O_SENSE.t42 0.20525
R346 O_SENSE.n57 O_SENSE.t18 0.20525
R347 O_SENSE.n57 O_SENSE.t17 0.20525
R348 O_SENSE.n59 O_SENSE.t62 0.20525
R349 O_SENSE.n59 O_SENSE.t61 0.20525
R350 O_SENSE.n61 O_SENSE.n60 0.189974
R351 O_SENSE.n60 O_SENSE.n58 0.189974
R352 O_SENSE.n58 O_SENSE.n56 0.189974
R353 O_SENSE.n56 O_SENSE.n54 0.189974
R354 O_SENSE.n54 O_SENSE.n52 0.189974
R355 O_SENSE.n52 O_SENSE.n50 0.189974
R356 O_SENSE.n50 O_SENSE.n48 0.189974
R357 O_SENSE.n48 O_SENSE.n46 0.189974
R358 O_SENSE.n46 O_SENSE.n44 0.189974
R359 O_SENSE.n44 O_SENSE.n42 0.189974
R360 O_SENSE.n42 O_SENSE.n40 0.189974
R361 O_SENSE.n40 O_SENSE.n38 0.189974
R362 O_SENSE.n38 O_SENSE.n36 0.189974
R363 O_SENSE.n36 O_SENSE.n34 0.189974
R364 O_SENSE.n34 O_SENSE.n32 0.189974
R365 O_SENSE.n30 O_SENSE.n29 0.189974
R366 O_SENSE.n29 O_SENSE.n27 0.189974
R367 O_SENSE.n27 O_SENSE.n25 0.189974
R368 O_SENSE.n25 O_SENSE.n23 0.189974
R369 O_SENSE.n23 O_SENSE.n21 0.189974
R370 O_SENSE.n21 O_SENSE.n19 0.189974
R371 O_SENSE.n19 O_SENSE.n17 0.189974
R372 O_SENSE.n17 O_SENSE.n15 0.189974
R373 O_SENSE.n15 O_SENSE.n13 0.189974
R374 O_SENSE.n13 O_SENSE.n11 0.189974
R375 O_SENSE.n11 O_SENSE.n9 0.189974
R376 O_SENSE.n9 O_SENSE.n7 0.189974
R377 O_SENSE.n7 O_SENSE.n5 0.189974
R378 O_SENSE.n5 O_SENSE.n3 0.189974
R379 O_SENSE.n3 O_SENSE.n1 0.189974
R380 O_CAPTURE_CLK O_CAPTURE_CLK.n14 7.98157
R381 O_CAPTURE_CLK.n14 O_CAPTURE_CLK.n6 6.5392
R382 O_CAPTURE_CLK.n8 O_CAPTURE_CLK.t12 5.7796
R383 O_CAPTURE_CLK.n1 O_CAPTURE_CLK.t14 5.73764
R384 O_CAPTURE_CLK.n13 O_CAPTURE_CLK.t5 5.59012
R385 O_CAPTURE_CLK.n6 O_CAPTURE_CLK.t11 5.54817
R386 O_CAPTURE_CLK.n8 O_CAPTURE_CLK.n7 5.38537
R387 O_CAPTURE_CLK.n10 O_CAPTURE_CLK.n9 5.38537
R388 O_CAPTURE_CLK.n12 O_CAPTURE_CLK.n11 5.38537
R389 O_CAPTURE_CLK.n1 O_CAPTURE_CLK.n0 5.32067
R390 O_CAPTURE_CLK.n3 O_CAPTURE_CLK.n2 5.32067
R391 O_CAPTURE_CLK.n5 O_CAPTURE_CLK.n4 5.32067
R392 O_CAPTURE_CLK.n14 O_CAPTURE_CLK.n13 4.61063
R393 O_CAPTURE_CLK.n0 O_CAPTURE_CLK.t6 0.228
R394 O_CAPTURE_CLK.n0 O_CAPTURE_CLK.t15 0.228
R395 O_CAPTURE_CLK.n2 O_CAPTURE_CLK.t0 0.228
R396 O_CAPTURE_CLK.n2 O_CAPTURE_CLK.t7 0.228
R397 O_CAPTURE_CLK.n4 O_CAPTURE_CLK.t10 0.228
R398 O_CAPTURE_CLK.n4 O_CAPTURE_CLK.t1 0.228
R399 O_CAPTURE_CLK.n7 O_CAPTURE_CLK.t8 0.20525
R400 O_CAPTURE_CLK.n7 O_CAPTURE_CLK.t13 0.20525
R401 O_CAPTURE_CLK.n9 O_CAPTURE_CLK.t2 0.20525
R402 O_CAPTURE_CLK.n9 O_CAPTURE_CLK.t9 0.20525
R403 O_CAPTURE_CLK.n11 O_CAPTURE_CLK.t4 0.20525
R404 O_CAPTURE_CLK.n11 O_CAPTURE_CLK.t3 0.20525
R405 O_CAPTURE_CLK.n13 O_CAPTURE_CLK.n12 0.189974
R406 O_CAPTURE_CLK.n12 O_CAPTURE_CLK.n10 0.189974
R407 O_CAPTURE_CLK.n10 O_CAPTURE_CLK.n8 0.189974
R408 O_CAPTURE_CLK.n6 O_CAPTURE_CLK.n5 0.189974
R409 O_CAPTURE_CLK.n5 O_CAPTURE_CLK.n3 0.189974
R410 O_CAPTURE_CLK.n3 O_CAPTURE_CLK.n1 0.189974
R411 O_CAPTURE_CLKB O_CAPTURE_CLKB.n14 6.63157
R412 O_CAPTURE_CLKB.n14 O_CAPTURE_CLKB.n6 6.5392
R413 O_CAPTURE_CLKB.n8 O_CAPTURE_CLKB.t9 5.7796
R414 O_CAPTURE_CLKB.n1 O_CAPTURE_CLKB.t13 5.73764
R415 O_CAPTURE_CLKB.n13 O_CAPTURE_CLKB.t8 5.59012
R416 O_CAPTURE_CLKB.n6 O_CAPTURE_CLKB.t12 5.54817
R417 O_CAPTURE_CLKB.n8 O_CAPTURE_CLKB.n7 5.38537
R418 O_CAPTURE_CLKB.n10 O_CAPTURE_CLKB.n9 5.38537
R419 O_CAPTURE_CLKB.n12 O_CAPTURE_CLKB.n11 5.38537
R420 O_CAPTURE_CLKB.n1 O_CAPTURE_CLKB.n0 5.32067
R421 O_CAPTURE_CLKB.n3 O_CAPTURE_CLKB.n2 5.32067
R422 O_CAPTURE_CLKB.n5 O_CAPTURE_CLKB.n4 5.32067
R423 O_CAPTURE_CLKB.n14 O_CAPTURE_CLKB.n13 4.61063
R424 O_CAPTURE_CLKB.n0 O_CAPTURE_CLKB.t0 0.228
R425 O_CAPTURE_CLKB.n0 O_CAPTURE_CLKB.t14 0.228
R426 O_CAPTURE_CLKB.n2 O_CAPTURE_CLKB.t5 0.228
R427 O_CAPTURE_CLKB.n2 O_CAPTURE_CLKB.t1 0.228
R428 O_CAPTURE_CLKB.n4 O_CAPTURE_CLKB.t11 0.228
R429 O_CAPTURE_CLKB.n4 O_CAPTURE_CLKB.t6 0.228
R430 O_CAPTURE_CLKB.n7 O_CAPTURE_CLKB.t3 0.20525
R431 O_CAPTURE_CLKB.n7 O_CAPTURE_CLKB.t15 0.20525
R432 O_CAPTURE_CLKB.n9 O_CAPTURE_CLKB.t4 0.20525
R433 O_CAPTURE_CLKB.n9 O_CAPTURE_CLKB.t2 0.20525
R434 O_CAPTURE_CLKB.n11 O_CAPTURE_CLKB.t7 0.20525
R435 O_CAPTURE_CLKB.n11 O_CAPTURE_CLKB.t10 0.20525
R436 O_CAPTURE_CLKB.n13 O_CAPTURE_CLKB.n12 0.189974
R437 O_CAPTURE_CLKB.n12 O_CAPTURE_CLKB.n10 0.189974
R438 O_CAPTURE_CLKB.n10 O_CAPTURE_CLKB.n8 0.189974
R439 O_CAPTURE_CLKB.n6 O_CAPTURE_CLKB.n5 0.189974
R440 O_CAPTURE_CLKB.n5 O_CAPTURE_CLKB.n3 0.189974
R441 O_CAPTURE_CLKB.n3 O_CAPTURE_CLKB.n1 0.189974
R442 CLKN_H.n8 CLKN_H.t3 113.632
R443 CLKN_H.n5 CLKN_H.t0 113.632
R444 CLKN_H.n0 CLKN_H.t4 113.632
R445 CLKN_H.n3 CLKN_H.t7 113.632
R446 CLKN_H.n6 CLKN_H.t1 109.174
R447 CLKN_H.n7 CLKN_H.t2 109.174
R448 CLKN_H.n1 CLKN_H.t5 109.174
R449 CLKN_H.n2 CLKN_H.t6 109.174
R450 CLKN_H CLKN_H.n10 15.3874
R451 CLKN_H.n7 CLKN_H.n6 11.6805
R452 CLKN_H.n2 CLKN_H.n1 11.6805
R453 CLKN_H.n10 CLKN_H.n4 10.9291
R454 CLKN_H.n10 CLKN_H.n9 9.0005
R455 CLKN_H.n9 CLKN_H.n5 7.10487
R456 CLKN_H.n9 CLKN_H.n8 7.10487
R457 CLKN_H.n4 CLKN_H.n0 7.10487
R458 CLKN_H.n4 CLKN_H.n3 7.10487
R459 CLKN_H.n6 CLKN_H.n5 4.42851
R460 CLKN_H.n8 CLKN_H.n7 4.42851
R461 CLKN_H.n1 CLKN_H.n0 4.42851
R462 CLKN_H.n3 CLKN_H.n2 4.42851
R463 CLKN_HB.n8 CLKN_HB.t3 113.632
R464 CLKN_HB.n5 CLKN_HB.t0 113.632
R465 CLKN_HB.n3 CLKN_HB.t11 113.632
R466 CLKN_HB.n0 CLKN_HB.t8 113.632
R467 CLKN_HB.n19 CLKN_HB.t7 113.632
R468 CLKN_HB.n16 CLKN_HB.t4 113.632
R469 CLKN_HB.n11 CLKN_HB.t12 113.632
R470 CLKN_HB.n14 CLKN_HB.t15 113.632
R471 CLKN_HB.n6 CLKN_HB.t1 109.174
R472 CLKN_HB.n7 CLKN_HB.t2 109.174
R473 CLKN_HB.n1 CLKN_HB.t9 109.174
R474 CLKN_HB.n2 CLKN_HB.t10 109.174
R475 CLKN_HB.n17 CLKN_HB.t5 109.174
R476 CLKN_HB.n18 CLKN_HB.t6 109.174
R477 CLKN_HB.n12 CLKN_HB.t13 109.174
R478 CLKN_HB.n13 CLKN_HB.t14 109.174
R479 CLKN_HB.n7 CLKN_HB.n6 11.6805
R480 CLKN_HB.n2 CLKN_HB.n1 11.6805
R481 CLKN_HB.n18 CLKN_HB.n17 11.6805
R482 CLKN_HB.n13 CLKN_HB.n12 11.6805
R483 CLKN_HB.n10 CLKN_HB.n4 10.9291
R484 CLKN_HB.n21 CLKN_HB.n15 10.9291
R485 CLKN_HB CLKN_HB.n22 9.03615
R486 CLKN_HB.n10 CLKN_HB.n9 9.0005
R487 CLKN_HB.n21 CLKN_HB.n20 9.0005
R488 CLKN_HB.n22 CLKN_HB.n10 8.70954
R489 CLKN_HB.n9 CLKN_HB.n5 7.10487
R490 CLKN_HB.n9 CLKN_HB.n8 7.10487
R491 CLKN_HB.n4 CLKN_HB.n0 7.10487
R492 CLKN_HB.n4 CLKN_HB.n3 7.10487
R493 CLKN_HB.n20 CLKN_HB.n16 7.10487
R494 CLKN_HB.n20 CLKN_HB.n19 7.10487
R495 CLKN_HB.n15 CLKN_HB.n11 7.10487
R496 CLKN_HB.n15 CLKN_HB.n14 7.10487
R497 CLKN_HB.n22 CLKN_HB.n21 4.59693
R498 CLKN_HB.n6 CLKN_HB.n5 4.42851
R499 CLKN_HB.n8 CLKN_HB.n7 4.42851
R500 CLKN_HB.n1 CLKN_HB.n0 4.42851
R501 CLKN_HB.n3 CLKN_HB.n2 4.42851
R502 CLKN_HB.n17 CLKN_HB.n16 4.42851
R503 CLKN_HB.n19 CLKN_HB.n18 4.42851
R504 CLKN_HB.n12 CLKN_HB.n11 4.42851
R505 CLKN_HB.n14 CLKN_HB.n13 4.42851
R506 VDD.t240 VDD.t260 450.829
R507 VDD.t254 VDD.t246 450.829
R508 VDD.t152 VDD.t248 450.829
R509 VDD.t194 VDD.t170 450.829
R510 VDD.t72 VDD.t284 450.829
R511 VDD.t212 VDD.t200 450.829
R512 VDD.t264 VDD.t232 450.829
R513 VDD.t238 VDD.t270 450.829
R514 VDD.t66 VDD.t234 450.829
R515 VDD.t186 VDD.t274 450.829
R516 VDD.t92 VDD.t204 450.829
R517 VDD.t62 VDD.t94 450.829
R518 VDD.t258 VDD.n79 417.582
R519 VDD.t226 VDD.n1 417.582
R520 VDD.n80 VDD.t126 245.21
R521 VDD.n2 VDD.t64 245.21
R522 VDD.t256 VDD.t258 44.1994
R523 VDD.t252 VDD.t256 44.1994
R524 VDD.t260 VDD.t252 44.1994
R525 VDD.t242 VDD.t240 44.1994
R526 VDD.t244 VDD.t242 44.1994
R527 VDD.t246 VDD.t244 44.1994
R528 VDD.t250 VDD.t254 44.1994
R529 VDD.t262 VDD.t250 44.1994
R530 VDD.t248 VDD.t262 44.1994
R531 VDD.t150 VDD.t152 44.1994
R532 VDD.t88 VDD.t150 44.1994
R533 VDD.t86 VDD.t88 44.1994
R534 VDD.t36 VDD.t86 44.1994
R535 VDD.t34 VDD.t36 44.1994
R536 VDD.t172 VDD.t34 44.1994
R537 VDD.t170 VDD.t172 44.1994
R538 VDD.t192 VDD.t194 44.1994
R539 VDD.t32 VDD.t192 44.1994
R540 VDD.t30 VDD.t32 44.1994
R541 VDD.t112 VDD.t30 44.1994
R542 VDD.t110 VDD.t112 44.1994
R543 VDD.t286 VDD.t110 44.1994
R544 VDD.t284 VDD.t286 44.1994
R545 VDD.t70 VDD.t72 44.1994
R546 VDD.t130 VDD.t70 44.1994
R547 VDD.t128 VDD.t130 44.1994
R548 VDD.t282 VDD.t128 44.1994
R549 VDD.t280 VDD.t282 44.1994
R550 VDD.t278 VDD.t280 44.1994
R551 VDD.t276 VDD.t278 44.1994
R552 VDD.t222 VDD.t276 44.1994
R553 VDD.t220 VDD.t222 44.1994
R554 VDD.t202 VDD.t220 44.1994
R555 VDD.t200 VDD.t202 44.1994
R556 VDD.t42 VDD.t212 44.1994
R557 VDD.t114 VDD.t42 44.1994
R558 VDD.t74 VDD.t114 44.1994
R559 VDD.t4 VDD.t74 44.1994
R560 VDD.t44 VDD.t4 44.1994
R561 VDD.t116 VDD.t44 44.1994
R562 VDD.t76 VDD.t116 44.1994
R563 VDD.t6 VDD.t76 44.1994
R564 VDD.t46 VDD.t6 44.1994
R565 VDD.t118 VDD.t46 44.1994
R566 VDD.t174 VDD.t118 44.1994
R567 VDD.t188 VDD.t174 44.1994
R568 VDD.t144 VDD.t188 44.1994
R569 VDD.t78 VDD.t144 44.1994
R570 VDD.t8 VDD.t78 44.1994
R571 VDD.t48 VDD.t8 44.1994
R572 VDD.t120 VDD.t48 44.1994
R573 VDD.t156 VDD.t120 44.1994
R574 VDD.t272 VDD.t156 44.1994
R575 VDD.t50 VDD.t272 44.1994
R576 VDD.t124 VDD.t50 44.1994
R577 VDD.t122 VDD.t124 44.1994
R578 VDD.t210 VDD.t122 44.1994
R579 VDD.t208 VDD.t210 44.1994
R580 VDD.t82 VDD.t208 44.1994
R581 VDD.t80 VDD.t82 44.1994
R582 VDD.t12 VDD.t80 44.1994
R583 VDD.t10 VDD.t12 44.1994
R584 VDD.t54 VDD.t10 44.1994
R585 VDD.t52 VDD.t54 44.1994
R586 VDD.t126 VDD.t52 44.1994
R587 VDD.t228 VDD.t226 44.1994
R588 VDD.t230 VDD.t228 44.1994
R589 VDD.t232 VDD.t230 44.1994
R590 VDD.t266 VDD.t264 44.1994
R591 VDD.t268 VDD.t266 44.1994
R592 VDD.t270 VDD.t268 44.1994
R593 VDD.t236 VDD.t238 44.1994
R594 VDD.t224 VDD.t236 44.1994
R595 VDD.t234 VDD.t224 44.1994
R596 VDD.t180 VDD.t66 44.1994
R597 VDD.t28 VDD.t180 44.1994
R598 VDD.t108 VDD.t28 44.1994
R599 VDD.t100 VDD.t108 44.1994
R600 VDD.t68 VDD.t100 44.1994
R601 VDD.t190 VDD.t68 44.1994
R602 VDD.t274 VDD.t190 44.1994
R603 VDD.t132 VDD.t186 44.1994
R604 VDD.t134 VDD.t132 44.1994
R605 VDD.t142 VDD.t134 44.1994
R606 VDD.t136 VDD.t142 44.1994
R607 VDD.t154 VDD.t136 44.1994
R608 VDD.t206 VDD.t154 44.1994
R609 VDD.t204 VDD.t206 44.1994
R610 VDD.t90 VDD.t92 44.1994
R611 VDD.t40 VDD.t90 44.1994
R612 VDD.t38 VDD.t40 44.1994
R613 VDD.t184 VDD.t38 44.1994
R614 VDD.t182 VDD.t184 44.1994
R615 VDD.t2 VDD.t182 44.1994
R616 VDD.t0 VDD.t2 44.1994
R617 VDD.t104 VDD.t0 44.1994
R618 VDD.t102 VDD.t104 44.1994
R619 VDD.t96 VDD.t102 44.1994
R620 VDD.t94 VDD.t96 44.1994
R621 VDD.t106 VDD.t62 44.1994
R622 VDD.t178 VDD.t106 44.1994
R623 VDD.t198 VDD.t178 44.1994
R624 VDD.t148 VDD.t198 44.1994
R625 VDD.t196 VDD.t148 44.1994
R626 VDD.t176 VDD.t196 44.1994
R627 VDD.t20 VDD.t176 44.1994
R628 VDD.t218 VDD.t20 44.1994
R629 VDD.t18 VDD.t218 44.1994
R630 VDD.t22 VDD.t18 44.1994
R631 VDD.t98 VDD.t22 44.1994
R632 VDD.t84 VDD.t98 44.1994
R633 VDD.t56 VDD.t84 44.1994
R634 VDD.t146 VDD.t56 44.1994
R635 VDD.t140 VDD.t146 44.1994
R636 VDD.t138 VDD.t140 44.1994
R637 VDD.t216 VDD.t138 44.1994
R638 VDD.t214 VDD.t216 44.1994
R639 VDD.t60 VDD.t214 44.1994
R640 VDD.t58 VDD.t60 44.1994
R641 VDD.t26 VDD.t58 44.1994
R642 VDD.t24 VDD.t26 44.1994
R643 VDD.t168 VDD.t24 44.1994
R644 VDD.t166 VDD.t168 44.1994
R645 VDD.t164 VDD.t166 44.1994
R646 VDD.t162 VDD.t164 44.1994
R647 VDD.t16 VDD.t162 44.1994
R648 VDD.t14 VDD.t16 44.1994
R649 VDD.t160 VDD.t14 44.1994
R650 VDD.t158 VDD.t160 44.1994
R651 VDD.t64 VDD.t158 44.1994
R652 VDD.n112 VDD.n111 11.1661
R653 VDD.n124 VDD.n123 11.1661
R654 VDD.n132 VDD.n131 11.1661
R655 VDD.n140 VDD.n139 11.1661
R656 VDD.n144 VDD.n143 11.1661
R657 VDD.n148 VDD.n147 11.1661
R658 VDD.n152 VDD.n151 11.1661
R659 VDD.n34 VDD.n33 11.1661
R660 VDD.n46 VDD.n45 11.1661
R661 VDD.n54 VDD.n53 11.1661
R662 VDD.n62 VDD.n61 11.1661
R663 VDD.n66 VDD.n65 11.1661
R664 VDD.n70 VDD.n69 11.1661
R665 VDD.n74 VDD.n73 11.1661
R666 VDD.n83 VDD.n81 5.51014
R667 VDD.n115 VDD.n113 5.51014
R668 VDD.n127 VDD.n125 5.51014
R669 VDD.n135 VDD.n133 5.51014
R670 VDD.n143 VDD.n141 5.51014
R671 VDD.n147 VDD.n145 5.51014
R672 VDD.n151 VDD.n149 5.51014
R673 VDD.n5 VDD.n3 5.51014
R674 VDD.n37 VDD.n35 5.51014
R675 VDD.n49 VDD.n47 5.51014
R676 VDD.n57 VDD.n55 5.51014
R677 VDD.n65 VDD.n63 5.51014
R678 VDD.n69 VDD.n67 5.51014
R679 VDD.n73 VDD.n71 5.51014
R680 VDD.n111 VDD.n110 5.32067
R681 VDD.n109 VDD.n108 5.32067
R682 VDD.n107 VDD.n106 5.32067
R683 VDD.n105 VDD.n104 5.32067
R684 VDD.n103 VDD.n102 5.32067
R685 VDD.n101 VDD.n100 5.32067
R686 VDD.n99 VDD.n98 5.32067
R687 VDD.n97 VDD.n96 5.32067
R688 VDD.n95 VDD.n94 5.32067
R689 VDD.n93 VDD.n92 5.32067
R690 VDD.n91 VDD.n90 5.32067
R691 VDD.n89 VDD.n88 5.32067
R692 VDD.n87 VDD.n86 5.32067
R693 VDD.n85 VDD.n84 5.32067
R694 VDD.n83 VDD.n82 5.32067
R695 VDD.n123 VDD.n122 5.32067
R696 VDD.n121 VDD.n120 5.32067
R697 VDD.n119 VDD.n118 5.32067
R698 VDD.n117 VDD.n116 5.32067
R699 VDD.n115 VDD.n114 5.32067
R700 VDD.n131 VDD.n130 5.32067
R701 VDD.n129 VDD.n128 5.32067
R702 VDD.n127 VDD.n126 5.32067
R703 VDD.n139 VDD.n138 5.32067
R704 VDD.n137 VDD.n136 5.32067
R705 VDD.n135 VDD.n134 5.32067
R706 VDD.n143 VDD.n142 5.32067
R707 VDD.n147 VDD.n146 5.32067
R708 VDD.n151 VDD.n150 5.32067
R709 VDD.n33 VDD.n32 5.32067
R710 VDD.n31 VDD.n30 5.32067
R711 VDD.n29 VDD.n28 5.32067
R712 VDD.n27 VDD.n26 5.32067
R713 VDD.n25 VDD.n24 5.32067
R714 VDD.n23 VDD.n22 5.32067
R715 VDD.n21 VDD.n20 5.32067
R716 VDD.n19 VDD.n18 5.32067
R717 VDD.n17 VDD.n16 5.32067
R718 VDD.n15 VDD.n14 5.32067
R719 VDD.n13 VDD.n12 5.32067
R720 VDD.n11 VDD.n10 5.32067
R721 VDD.n9 VDD.n8 5.32067
R722 VDD.n7 VDD.n6 5.32067
R723 VDD.n5 VDD.n4 5.32067
R724 VDD.n45 VDD.n44 5.32067
R725 VDD.n43 VDD.n42 5.32067
R726 VDD.n41 VDD.n40 5.32067
R727 VDD.n39 VDD.n38 5.32067
R728 VDD.n37 VDD.n36 5.32067
R729 VDD.n53 VDD.n52 5.32067
R730 VDD.n51 VDD.n50 5.32067
R731 VDD.n49 VDD.n48 5.32067
R732 VDD.n61 VDD.n60 5.32067
R733 VDD.n59 VDD.n58 5.32067
R734 VDD.n57 VDD.n56 5.32067
R735 VDD.n65 VDD.n64 5.32067
R736 VDD.n69 VDD.n68 5.32067
R737 VDD.n73 VDD.n72 5.32067
R738 VDD.n78 VDD.n0 4.5005
R739 VDD.n156 VDD.n0 4.5005
R740 VDD.n78 VDD.n77 3.31026
R741 VDD.n156 VDD.n155 2.76928
R742 VDD.n158 VDD.n157 2.26839
R743 VDD.n155 VDD.n154 2.2545
R744 VDD.n77 VDD.n76 2.2545
R745 VDD.n154 VDD.n153 2.2505
R746 VDD.n76 VDD.n75 2.2505
R747 VDD.n154 VDD.n80 1.86985
R748 VDD.n76 VDD.n2 1.86985
R749 VDD VDD.n158 1.13544
R750 VDD.n124 VDD.n112 0.7421
R751 VDD.n46 VDD.n34 0.7421
R752 VDD.n132 VDD.n124 0.3821
R753 VDD.n54 VDD.n46 0.3821
R754 VDD.n144 VDD.n140 0.3101
R755 VDD.n140 VDD.n132 0.3101
R756 VDD.n66 VDD.n62 0.3101
R757 VDD.n62 VDD.n54 0.3101
R758 VDD.n152 VDD.n148 0.2381
R759 VDD.n148 VDD.n144 0.2381
R760 VDD.n74 VDD.n70 0.2381
R761 VDD.n70 VDD.n66 0.2381
R762 VDD.n153 VDD.n152 0.236975
R763 VDD.n75 VDD.n74 0.236975
R764 VDD.n110 VDD.t53 0.228
R765 VDD.n110 VDD.t127 0.228
R766 VDD.n108 VDD.t11 0.228
R767 VDD.n108 VDD.t55 0.228
R768 VDD.n106 VDD.t81 0.228
R769 VDD.n106 VDD.t13 0.228
R770 VDD.n104 VDD.t209 0.228
R771 VDD.n104 VDD.t83 0.228
R772 VDD.n102 VDD.t123 0.228
R773 VDD.n102 VDD.t211 0.228
R774 VDD.n100 VDD.t51 0.228
R775 VDD.n100 VDD.t125 0.228
R776 VDD.n98 VDD.t157 0.228
R777 VDD.n98 VDD.t273 0.228
R778 VDD.n96 VDD.t49 0.228
R779 VDD.n96 VDD.t121 0.228
R780 VDD.n94 VDD.t79 0.228
R781 VDD.n94 VDD.t9 0.228
R782 VDD.n92 VDD.t189 0.228
R783 VDD.n92 VDD.t145 0.228
R784 VDD.n90 VDD.t119 0.228
R785 VDD.n90 VDD.t175 0.228
R786 VDD.n88 VDD.t7 0.228
R787 VDD.n88 VDD.t47 0.228
R788 VDD.n86 VDD.t117 0.228
R789 VDD.n86 VDD.t77 0.228
R790 VDD.n84 VDD.t5 0.228
R791 VDD.n84 VDD.t45 0.228
R792 VDD.n82 VDD.t115 0.228
R793 VDD.n82 VDD.t75 0.228
R794 VDD.n81 VDD.t213 0.228
R795 VDD.n81 VDD.t43 0.228
R796 VDD.n122 VDD.t203 0.228
R797 VDD.n122 VDD.t201 0.228
R798 VDD.n120 VDD.t223 0.228
R799 VDD.n120 VDD.t221 0.228
R800 VDD.n118 VDD.t279 0.228
R801 VDD.n118 VDD.t277 0.228
R802 VDD.n116 VDD.t283 0.228
R803 VDD.n116 VDD.t281 0.228
R804 VDD.n114 VDD.t131 0.228
R805 VDD.n114 VDD.t129 0.228
R806 VDD.n113 VDD.t73 0.228
R807 VDD.n113 VDD.t71 0.228
R808 VDD.n130 VDD.t287 0.228
R809 VDD.n130 VDD.t285 0.228
R810 VDD.n128 VDD.t113 0.228
R811 VDD.n128 VDD.t111 0.228
R812 VDD.n126 VDD.t33 0.228
R813 VDD.n126 VDD.t31 0.228
R814 VDD.n125 VDD.t195 0.228
R815 VDD.n125 VDD.t193 0.228
R816 VDD.n138 VDD.t173 0.228
R817 VDD.n138 VDD.t171 0.228
R818 VDD.n136 VDD.t37 0.228
R819 VDD.n136 VDD.t35 0.228
R820 VDD.n134 VDD.t89 0.228
R821 VDD.n134 VDD.t87 0.228
R822 VDD.n133 VDD.t153 0.228
R823 VDD.n133 VDD.t151 0.228
R824 VDD.n142 VDD.t263 0.228
R825 VDD.n142 VDD.t249 0.228
R826 VDD.n141 VDD.t255 0.228
R827 VDD.n141 VDD.t251 0.228
R828 VDD.n146 VDD.t245 0.228
R829 VDD.n146 VDD.t247 0.228
R830 VDD.n145 VDD.t241 0.228
R831 VDD.n145 VDD.t243 0.228
R832 VDD.n150 VDD.t253 0.228
R833 VDD.n150 VDD.t261 0.228
R834 VDD.n149 VDD.t259 0.228
R835 VDD.n149 VDD.t257 0.228
R836 VDD.n32 VDD.t159 0.228
R837 VDD.n32 VDD.t65 0.228
R838 VDD.n30 VDD.t15 0.228
R839 VDD.n30 VDD.t161 0.228
R840 VDD.n28 VDD.t163 0.228
R841 VDD.n28 VDD.t17 0.228
R842 VDD.n26 VDD.t167 0.228
R843 VDD.n26 VDD.t165 0.228
R844 VDD.n24 VDD.t25 0.228
R845 VDD.n24 VDD.t169 0.228
R846 VDD.n22 VDD.t59 0.228
R847 VDD.n22 VDD.t27 0.228
R848 VDD.n20 VDD.t215 0.228
R849 VDD.n20 VDD.t61 0.228
R850 VDD.n18 VDD.t139 0.228
R851 VDD.n18 VDD.t217 0.228
R852 VDD.n16 VDD.t147 0.228
R853 VDD.n16 VDD.t141 0.228
R854 VDD.n14 VDD.t85 0.228
R855 VDD.n14 VDD.t57 0.228
R856 VDD.n12 VDD.t23 0.228
R857 VDD.n12 VDD.t99 0.228
R858 VDD.n10 VDD.t219 0.228
R859 VDD.n10 VDD.t19 0.228
R860 VDD.n8 VDD.t177 0.228
R861 VDD.n8 VDD.t21 0.228
R862 VDD.n6 VDD.t149 0.228
R863 VDD.n6 VDD.t197 0.228
R864 VDD.n4 VDD.t179 0.228
R865 VDD.n4 VDD.t199 0.228
R866 VDD.n3 VDD.t63 0.228
R867 VDD.n3 VDD.t107 0.228
R868 VDD.n44 VDD.t97 0.228
R869 VDD.n44 VDD.t95 0.228
R870 VDD.n42 VDD.t105 0.228
R871 VDD.n42 VDD.t103 0.228
R872 VDD.n40 VDD.t3 0.228
R873 VDD.n40 VDD.t1 0.228
R874 VDD.n38 VDD.t185 0.228
R875 VDD.n38 VDD.t183 0.228
R876 VDD.n36 VDD.t41 0.228
R877 VDD.n36 VDD.t39 0.228
R878 VDD.n35 VDD.t93 0.228
R879 VDD.n35 VDD.t91 0.228
R880 VDD.n52 VDD.t207 0.228
R881 VDD.n52 VDD.t205 0.228
R882 VDD.n50 VDD.t137 0.228
R883 VDD.n50 VDD.t155 0.228
R884 VDD.n48 VDD.t135 0.228
R885 VDD.n48 VDD.t143 0.228
R886 VDD.n47 VDD.t187 0.228
R887 VDD.n47 VDD.t133 0.228
R888 VDD.n60 VDD.t191 0.228
R889 VDD.n60 VDD.t275 0.228
R890 VDD.n58 VDD.t101 0.228
R891 VDD.n58 VDD.t69 0.228
R892 VDD.n56 VDD.t29 0.228
R893 VDD.n56 VDD.t109 0.228
R894 VDD.n55 VDD.t67 0.228
R895 VDD.n55 VDD.t181 0.228
R896 VDD.n64 VDD.t225 0.228
R897 VDD.n64 VDD.t235 0.228
R898 VDD.n63 VDD.t239 0.228
R899 VDD.n63 VDD.t237 0.228
R900 VDD.n68 VDD.t269 0.228
R901 VDD.n68 VDD.t271 0.228
R902 VDD.n67 VDD.t265 0.228
R903 VDD.n67 VDD.t267 0.228
R904 VDD.n72 VDD.t231 0.228
R905 VDD.n72 VDD.t233 0.228
R906 VDD.n71 VDD.t227 0.228
R907 VDD.n71 VDD.t229 0.228
R908 VDD.n85 VDD.n83 0.189974
R909 VDD.n87 VDD.n85 0.189974
R910 VDD.n89 VDD.n87 0.189974
R911 VDD.n91 VDD.n89 0.189974
R912 VDD.n93 VDD.n91 0.189974
R913 VDD.n95 VDD.n93 0.189974
R914 VDD.n97 VDD.n95 0.189974
R915 VDD.n99 VDD.n97 0.189974
R916 VDD.n101 VDD.n99 0.189974
R917 VDD.n103 VDD.n101 0.189974
R918 VDD.n105 VDD.n103 0.189974
R919 VDD.n107 VDD.n105 0.189974
R920 VDD.n109 VDD.n107 0.189974
R921 VDD.n111 VDD.n109 0.189974
R922 VDD.n117 VDD.n115 0.189974
R923 VDD.n119 VDD.n117 0.189974
R924 VDD.n121 VDD.n119 0.189974
R925 VDD.n123 VDD.n121 0.189974
R926 VDD.n129 VDD.n127 0.189974
R927 VDD.n131 VDD.n129 0.189974
R928 VDD.n137 VDD.n135 0.189974
R929 VDD.n139 VDD.n137 0.189974
R930 VDD.n7 VDD.n5 0.189974
R931 VDD.n9 VDD.n7 0.189974
R932 VDD.n11 VDD.n9 0.189974
R933 VDD.n13 VDD.n11 0.189974
R934 VDD.n15 VDD.n13 0.189974
R935 VDD.n17 VDD.n15 0.189974
R936 VDD.n19 VDD.n17 0.189974
R937 VDD.n21 VDD.n19 0.189974
R938 VDD.n23 VDD.n21 0.189974
R939 VDD.n25 VDD.n23 0.189974
R940 VDD.n27 VDD.n25 0.189974
R941 VDD.n29 VDD.n27 0.189974
R942 VDD.n31 VDD.n29 0.189974
R943 VDD.n33 VDD.n31 0.189974
R944 VDD.n39 VDD.n37 0.189974
R945 VDD.n41 VDD.n39 0.189974
R946 VDD.n43 VDD.n41 0.189974
R947 VDD.n45 VDD.n43 0.189974
R948 VDD.n51 VDD.n49 0.189974
R949 VDD.n53 VDD.n51 0.189974
R950 VDD.n59 VDD.n57 0.189974
R951 VDD.n61 VDD.n59 0.189974
R952 VDD.n112 VDD.n80 0.0571608
R953 VDD.n34 VDD.n2 0.0571608
R954 VDD.n158 VDD.n0 0.020105
R955 VDD.n155 VDD.n79 0.00725
R956 VDD.n153 VDD.n79 0.00725
R957 VDD.n77 VDD.n1 0.00725
R958 VDD.n75 VDD.n1 0.00725
R959 VDD.n157 VDD.n156 0.0054955
R960 VDD.n157 VDD.n78 0.0054955
R961 VSS.n86 VSS.n85 5121.21
R962 VSS.n165 VSS.n86 5121.21
R963 VSS.n83 VSS.n82 4481.39
R964 VSS.n166 VSS.n165 4318.81
R965 VSS.n84 VSS.n83 3545.45
R966 VSS.n85 VSS.n84 3545.45
R967 VSS.t264 VSS.t228 1481.56
R968 VSS.t224 VSS.t270 1481.56
R969 VSS.t188 VSS.t238 1481.56
R970 VSS.t196 VSS.t222 1481.56
R971 VSS.t26 VSS.t198 1481.56
R972 VSS.t48 VSS.t0 1481.56
R973 VSS.t240 VSS.t248 1481.56
R974 VSS.t256 VSS.t246 1481.56
R975 VSS.t86 VSS.t252 1481.56
R976 VSS.t94 VSS.t102 1481.56
R977 VSS.t56 VSS.t200 1481.56
R978 VSS.t104 VSS.t280 1481.56
R979 VSS.t226 VSS.n4 1285.47
R980 VSS.n164 VSS.t250 1285.47
R981 VSS.n84 VSS.n3 933.923
R982 VSS.n85 VSS.n2 933.923
R983 VSS.n83 VSS.n4 907.822
R984 VSS.n165 VSS.n164 907.822
R985 VSS.n6 VSS.t278 743.221
R986 VSS.n160 VSS.t10 743.221
R987 VSS.n167 VSS.n86 351.702
R988 VSS.t232 VSS.t226 145.251
R989 VSS.t236 VSS.t232 145.251
R990 VSS.t228 VSS.t236 145.251
R991 VSS.t266 VSS.t264 145.251
R992 VSS.t268 VSS.t266 145.251
R993 VSS.t270 VSS.t268 145.251
R994 VSS.t234 VSS.t224 145.251
R995 VSS.t230 VSS.t234 145.251
R996 VSS.t238 VSS.t230 145.251
R997 VSS.t20 VSS.t188 145.251
R998 VSS.t190 VSS.t20 145.251
R999 VSS.t100 VSS.t190 145.251
R1000 VSS.t286 VSS.t100 145.251
R1001 VSS.t220 VSS.t286 145.251
R1002 VSS.t216 VSS.t220 145.251
R1003 VSS.t222 VSS.t216 145.251
R1004 VSS.t194 VSS.t196 145.251
R1005 VSS.t192 VSS.t194 145.251
R1006 VSS.t142 VSS.t192 145.251
R1007 VSS.t140 VSS.t142 145.251
R1008 VSS.t214 VSS.t140 145.251
R1009 VSS.t212 VSS.t214 145.251
R1010 VSS.t198 VSS.t212 145.251
R1011 VSS.t24 VSS.t26 145.251
R1012 VSS.t146 VSS.t24 145.251
R1013 VSS.t144 VSS.t146 145.251
R1014 VSS.t162 VSS.t144 145.251
R1015 VSS.t160 VSS.t162 145.251
R1016 VSS.t150 VSS.t160 145.251
R1017 VSS.t148 VSS.t150 145.251
R1018 VSS.t174 VSS.t148 145.251
R1019 VSS.t172 VSS.t174 145.251
R1020 VSS.t218 VSS.t172 145.251
R1021 VSS.t0 VSS.t218 145.251
R1022 VSS.t98 VSS.t48 145.251
R1023 VSS.t96 VSS.t98 145.251
R1024 VSS.t210 VSS.t96 145.251
R1025 VSS.t208 VSS.t210 145.251
R1026 VSS.t284 VSS.t208 145.251
R1027 VSS.t282 VSS.t284 145.251
R1028 VSS.t52 VSS.t282 145.251
R1029 VSS.t50 VSS.t52 145.251
R1030 VSS.t274 VSS.t50 145.251
R1031 VSS.t272 VSS.t274 145.251
R1032 VSS.t18 VSS.t272 145.251
R1033 VSS.t16 VSS.t18 145.251
R1034 VSS.t120 VSS.t16 145.251
R1035 VSS.t118 VSS.t120 145.251
R1036 VSS.t132 VSS.t118 145.251
R1037 VSS.t130 VSS.t132 145.251
R1038 VSS.t42 VSS.t130 145.251
R1039 VSS.t40 VSS.t42 145.251
R1040 VSS.t124 VSS.t40 145.251
R1041 VSS.t122 VSS.t124 145.251
R1042 VSS.t82 VSS.t122 145.251
R1043 VSS.t80 VSS.t82 145.251
R1044 VSS.t14 VSS.t80 145.251
R1045 VSS.t12 VSS.t14 145.251
R1046 VSS.t46 VSS.t12 145.251
R1047 VSS.t44 VSS.t46 145.251
R1048 VSS.t128 VSS.t44 145.251
R1049 VSS.t126 VSS.t128 145.251
R1050 VSS.t186 VSS.t126 145.251
R1051 VSS.t184 VSS.t186 145.251
R1052 VSS.t278 VSS.t184 145.251
R1053 VSS.t260 VSS.t250 145.251
R1054 VSS.t254 VSS.t260 145.251
R1055 VSS.t248 VSS.t254 145.251
R1056 VSS.t242 VSS.t240 145.251
R1057 VSS.t244 VSS.t242 145.251
R1058 VSS.t246 VSS.t244 145.251
R1059 VSS.t258 VSS.t256 145.251
R1060 VSS.t262 VSS.t258 145.251
R1061 VSS.t252 VSS.t262 145.251
R1062 VSS.t84 VSS.t86 145.251
R1063 VSS.t138 VSS.t84 145.251
R1064 VSS.t66 VSS.t138 145.251
R1065 VSS.t22 VSS.t66 145.251
R1066 VSS.t64 VSS.t22 145.251
R1067 VSS.t276 VSS.t64 145.251
R1068 VSS.t102 VSS.t276 145.251
R1069 VSS.t92 VSS.t94 145.251
R1070 VSS.t62 VSS.t92 145.251
R1071 VSS.t60 VSS.t62 145.251
R1072 VSS.t170 VSS.t60 145.251
R1073 VSS.t168 VSS.t170 145.251
R1074 VSS.t202 VSS.t168 145.251
R1075 VSS.t200 VSS.t202 145.251
R1076 VSS.t54 VSS.t56 145.251
R1077 VSS.t136 VSS.t54 145.251
R1078 VSS.t134 VSS.t136 145.251
R1079 VSS.t154 VSS.t134 145.251
R1080 VSS.t152 VSS.t154 145.251
R1081 VSS.t158 VSS.t152 145.251
R1082 VSS.t156 VSS.t158 145.251
R1083 VSS.t90 VSS.t156 145.251
R1084 VSS.t88 VSS.t90 145.251
R1085 VSS.t58 VSS.t88 145.251
R1086 VSS.t280 VSS.t58 145.251
R1087 VSS.t206 VSS.t104 145.251
R1088 VSS.t204 VSS.t206 145.251
R1089 VSS.t30 VSS.t204 145.251
R1090 VSS.t28 VSS.t30 145.251
R1091 VSS.t108 VSS.t28 145.251
R1092 VSS.t106 VSS.t108 145.251
R1093 VSS.t70 VSS.t106 145.251
R1094 VSS.t68 VSS.t70 145.251
R1095 VSS.t4 VSS.t68 145.251
R1096 VSS.t2 VSS.t4 145.251
R1097 VSS.t34 VSS.t2 145.251
R1098 VSS.t32 VSS.t34 145.251
R1099 VSS.t112 VSS.t32 145.251
R1100 VSS.t110 VSS.t112 145.251
R1101 VSS.t74 VSS.t110 145.251
R1102 VSS.t72 VSS.t74 145.251
R1103 VSS.t8 VSS.t72 145.251
R1104 VSS.t6 VSS.t8 145.251
R1105 VSS.t38 VSS.t6 145.251
R1106 VSS.t36 VSS.t38 145.251
R1107 VSS.t116 VSS.t36 145.251
R1108 VSS.t114 VSS.t116 145.251
R1109 VSS.t178 VSS.t114 145.251
R1110 VSS.t176 VSS.t178 145.251
R1111 VSS.t182 VSS.t176 145.251
R1112 VSS.t180 VSS.t182 145.251
R1113 VSS.t166 VSS.t180 145.251
R1114 VSS.t164 VSS.t166 145.251
R1115 VSS.t78 VSS.t164 145.251
R1116 VSS.t76 VSS.t78 145.251
R1117 VSS.t10 VSS.t76 145.251
R1118 VSS.n5 VSS.n4 24.2219
R1119 VSS.n164 VSS.n163 24.2219
R1120 VSS.n38 VSS.n37 9.9768
R1121 VSS.n50 VSS.n49 9.9768
R1122 VSS.n58 VSS.n57 9.9768
R1123 VSS.n66 VSS.n65 9.9768
R1124 VSS.n70 VSS.n69 9.9768
R1125 VSS.n74 VSS.n73 9.9768
R1126 VSS.n78 VSS.n77 9.9768
R1127 VSS.n159 VSS.n158 9.9768
R1128 VSS.n127 VSS.n126 9.9768
R1129 VSS.n115 VSS.n114 9.9768
R1130 VSS.n107 VSS.n106 9.9768
R1131 VSS.n99 VSS.n98 9.9768
R1132 VSS.n95 VSS.n94 9.9768
R1133 VSS.n91 VSS.n90 9.9768
R1134 VSS.n9 VSS.n7 5.57485
R1135 VSS.n41 VSS.n39 5.57485
R1136 VSS.n53 VSS.n51 5.57485
R1137 VSS.n61 VSS.n59 5.57485
R1138 VSS.n69 VSS.n67 5.57485
R1139 VSS.n73 VSS.n71 5.57485
R1140 VSS.n77 VSS.n75 5.57485
R1141 VSS.n130 VSS.n128 5.57485
R1142 VSS.n118 VSS.n116 5.57485
R1143 VSS.n110 VSS.n108 5.57485
R1144 VSS.n102 VSS.n100 5.57485
R1145 VSS.n98 VSS.n96 5.57485
R1146 VSS.n94 VSS.n92 5.57485
R1147 VSS.n90 VSS.n88 5.57485
R1148 VSS.n37 VSS.n36 5.38537
R1149 VSS.n35 VSS.n34 5.38537
R1150 VSS.n33 VSS.n32 5.38537
R1151 VSS.n31 VSS.n30 5.38537
R1152 VSS.n29 VSS.n28 5.38537
R1153 VSS.n27 VSS.n26 5.38537
R1154 VSS.n25 VSS.n24 5.38537
R1155 VSS.n23 VSS.n22 5.38537
R1156 VSS.n21 VSS.n20 5.38537
R1157 VSS.n19 VSS.n18 5.38537
R1158 VSS.n17 VSS.n16 5.38537
R1159 VSS.n15 VSS.n14 5.38537
R1160 VSS.n13 VSS.n12 5.38537
R1161 VSS.n11 VSS.n10 5.38537
R1162 VSS.n9 VSS.n8 5.38537
R1163 VSS.n49 VSS.n48 5.38537
R1164 VSS.n47 VSS.n46 5.38537
R1165 VSS.n45 VSS.n44 5.38537
R1166 VSS.n43 VSS.n42 5.38537
R1167 VSS.n41 VSS.n40 5.38537
R1168 VSS.n57 VSS.n56 5.38537
R1169 VSS.n55 VSS.n54 5.38537
R1170 VSS.n53 VSS.n52 5.38537
R1171 VSS.n65 VSS.n64 5.38537
R1172 VSS.n63 VSS.n62 5.38537
R1173 VSS.n61 VSS.n60 5.38537
R1174 VSS.n69 VSS.n68 5.38537
R1175 VSS.n73 VSS.n72 5.38537
R1176 VSS.n77 VSS.n76 5.38537
R1177 VSS.n158 VSS.n157 5.38537
R1178 VSS.n156 VSS.n155 5.38537
R1179 VSS.n154 VSS.n153 5.38537
R1180 VSS.n152 VSS.n151 5.38537
R1181 VSS.n150 VSS.n149 5.38537
R1182 VSS.n148 VSS.n147 5.38537
R1183 VSS.n146 VSS.n145 5.38537
R1184 VSS.n144 VSS.n143 5.38537
R1185 VSS.n142 VSS.n141 5.38537
R1186 VSS.n140 VSS.n139 5.38537
R1187 VSS.n138 VSS.n137 5.38537
R1188 VSS.n136 VSS.n135 5.38537
R1189 VSS.n134 VSS.n133 5.38537
R1190 VSS.n132 VSS.n131 5.38537
R1191 VSS.n130 VSS.n129 5.38537
R1192 VSS.n126 VSS.n125 5.38537
R1193 VSS.n124 VSS.n123 5.38537
R1194 VSS.n122 VSS.n121 5.38537
R1195 VSS.n120 VSS.n119 5.38537
R1196 VSS.n118 VSS.n117 5.38537
R1197 VSS.n114 VSS.n113 5.38537
R1198 VSS.n112 VSS.n111 5.38537
R1199 VSS.n110 VSS.n109 5.38537
R1200 VSS.n106 VSS.n105 5.38537
R1201 VSS.n104 VSS.n103 5.38537
R1202 VSS.n102 VSS.n101 5.38537
R1203 VSS.n98 VSS.n97 5.38537
R1204 VSS.n94 VSS.n93 5.38537
R1205 VSS.n90 VSS.n89 5.38537
R1206 VSS.n1 VSS.n0 4.5005
R1207 VSS.n168 VSS.n0 4.5005
R1208 VSS.n170 VSS.n169 2.26839
R1209 VSS.n81 VSS.n80 2.2545
R1210 VSS.n161 VSS.n87 2.2545
R1211 VSS.n80 VSS.n79 2.2505
R1212 VSS.n162 VSS.n161 2.2505
R1213 VSS.n82 VSS.n81 1.90124
R1214 VSS.n166 VSS.n87 1.90124
R1215 VSS.n80 VSS.n6 1.86985
R1216 VSS.n161 VSS.n160 1.86985
R1217 VSS VSS.n170 1.13544
R1218 VSS.n50 VSS.n38 0.7421
R1219 VSS.n159 VSS.n127 0.7421
R1220 VSS.n82 VSS.n3 0.543479
R1221 VSS.n3 VSS.n2 0.543479
R1222 VSS.n167 VSS.n166 0.543479
R1223 VSS.n2 VSS.n1 0.507615
R1224 VSS.n168 VSS.n167 0.507363
R1225 VSS.n58 VSS.n50 0.3821
R1226 VSS.n127 VSS.n115 0.3821
R1227 VSS.n70 VSS.n66 0.3101
R1228 VSS.n66 VSS.n58 0.3101
R1229 VSS.n107 VSS.n99 0.3101
R1230 VSS.n115 VSS.n107 0.3101
R1231 VSS.n78 VSS.n74 0.2381
R1232 VSS.n74 VSS.n70 0.2381
R1233 VSS.n95 VSS.n91 0.2381
R1234 VSS.n99 VSS.n95 0.2381
R1235 VSS.n79 VSS.n78 0.236975
R1236 VSS.n162 VSS.n91 0.236975
R1237 VSS.n36 VSS.t185 0.20525
R1238 VSS.n36 VSS.t279 0.20525
R1239 VSS.n34 VSS.t127 0.20525
R1240 VSS.n34 VSS.t187 0.20525
R1241 VSS.n32 VSS.t45 0.20525
R1242 VSS.n32 VSS.t129 0.20525
R1243 VSS.n30 VSS.t13 0.20525
R1244 VSS.n30 VSS.t47 0.20525
R1245 VSS.n28 VSS.t81 0.20525
R1246 VSS.n28 VSS.t15 0.20525
R1247 VSS.n26 VSS.t123 0.20525
R1248 VSS.n26 VSS.t83 0.20525
R1249 VSS.n24 VSS.t41 0.20525
R1250 VSS.n24 VSS.t125 0.20525
R1251 VSS.n22 VSS.t131 0.20525
R1252 VSS.n22 VSS.t43 0.20525
R1253 VSS.n20 VSS.t119 0.20525
R1254 VSS.n20 VSS.t133 0.20525
R1255 VSS.n18 VSS.t17 0.20525
R1256 VSS.n18 VSS.t121 0.20525
R1257 VSS.n16 VSS.t273 0.20525
R1258 VSS.n16 VSS.t19 0.20525
R1259 VSS.n14 VSS.t51 0.20525
R1260 VSS.n14 VSS.t275 0.20525
R1261 VSS.n12 VSS.t283 0.20525
R1262 VSS.n12 VSS.t53 0.20525
R1263 VSS.n10 VSS.t209 0.20525
R1264 VSS.n10 VSS.t285 0.20525
R1265 VSS.n8 VSS.t97 0.20525
R1266 VSS.n8 VSS.t211 0.20525
R1267 VSS.n7 VSS.t49 0.20525
R1268 VSS.n7 VSS.t99 0.20525
R1269 VSS.n48 VSS.t219 0.20525
R1270 VSS.n48 VSS.t1 0.20525
R1271 VSS.n46 VSS.t175 0.20525
R1272 VSS.n46 VSS.t173 0.20525
R1273 VSS.n44 VSS.t151 0.20525
R1274 VSS.n44 VSS.t149 0.20525
R1275 VSS.n42 VSS.t163 0.20525
R1276 VSS.n42 VSS.t161 0.20525
R1277 VSS.n40 VSS.t147 0.20525
R1278 VSS.n40 VSS.t145 0.20525
R1279 VSS.n39 VSS.t27 0.20525
R1280 VSS.n39 VSS.t25 0.20525
R1281 VSS.n56 VSS.t213 0.20525
R1282 VSS.n56 VSS.t199 0.20525
R1283 VSS.n54 VSS.t141 0.20525
R1284 VSS.n54 VSS.t215 0.20525
R1285 VSS.n52 VSS.t193 0.20525
R1286 VSS.n52 VSS.t143 0.20525
R1287 VSS.n51 VSS.t197 0.20525
R1288 VSS.n51 VSS.t195 0.20525
R1289 VSS.n64 VSS.t217 0.20525
R1290 VSS.n64 VSS.t223 0.20525
R1291 VSS.n62 VSS.t287 0.20525
R1292 VSS.n62 VSS.t221 0.20525
R1293 VSS.n60 VSS.t191 0.20525
R1294 VSS.n60 VSS.t101 0.20525
R1295 VSS.n59 VSS.t189 0.20525
R1296 VSS.n59 VSS.t21 0.20525
R1297 VSS.n68 VSS.t231 0.20525
R1298 VSS.n68 VSS.t239 0.20525
R1299 VSS.n67 VSS.t225 0.20525
R1300 VSS.n67 VSS.t235 0.20525
R1301 VSS.n72 VSS.t269 0.20525
R1302 VSS.n72 VSS.t271 0.20525
R1303 VSS.n71 VSS.t265 0.20525
R1304 VSS.n71 VSS.t267 0.20525
R1305 VSS.n76 VSS.t237 0.20525
R1306 VSS.n76 VSS.t229 0.20525
R1307 VSS.n75 VSS.t227 0.20525
R1308 VSS.n75 VSS.t233 0.20525
R1309 VSS.n157 VSS.t77 0.20525
R1310 VSS.n157 VSS.t11 0.20525
R1311 VSS.n155 VSS.t165 0.20525
R1312 VSS.n155 VSS.t79 0.20525
R1313 VSS.n153 VSS.t181 0.20525
R1314 VSS.n153 VSS.t167 0.20525
R1315 VSS.n151 VSS.t177 0.20525
R1316 VSS.n151 VSS.t183 0.20525
R1317 VSS.n149 VSS.t115 0.20525
R1318 VSS.n149 VSS.t179 0.20525
R1319 VSS.n147 VSS.t37 0.20525
R1320 VSS.n147 VSS.t117 0.20525
R1321 VSS.n145 VSS.t7 0.20525
R1322 VSS.n145 VSS.t39 0.20525
R1323 VSS.n143 VSS.t73 0.20525
R1324 VSS.n143 VSS.t9 0.20525
R1325 VSS.n141 VSS.t111 0.20525
R1326 VSS.n141 VSS.t75 0.20525
R1327 VSS.n139 VSS.t33 0.20525
R1328 VSS.n139 VSS.t113 0.20525
R1329 VSS.n137 VSS.t3 0.20525
R1330 VSS.n137 VSS.t35 0.20525
R1331 VSS.n135 VSS.t69 0.20525
R1332 VSS.n135 VSS.t5 0.20525
R1333 VSS.n133 VSS.t107 0.20525
R1334 VSS.n133 VSS.t71 0.20525
R1335 VSS.n131 VSS.t29 0.20525
R1336 VSS.n131 VSS.t109 0.20525
R1337 VSS.n129 VSS.t205 0.20525
R1338 VSS.n129 VSS.t31 0.20525
R1339 VSS.n128 VSS.t105 0.20525
R1340 VSS.n128 VSS.t207 0.20525
R1341 VSS.n125 VSS.t59 0.20525
R1342 VSS.n125 VSS.t281 0.20525
R1343 VSS.n123 VSS.t91 0.20525
R1344 VSS.n123 VSS.t89 0.20525
R1345 VSS.n121 VSS.t159 0.20525
R1346 VSS.n121 VSS.t157 0.20525
R1347 VSS.n119 VSS.t155 0.20525
R1348 VSS.n119 VSS.t153 0.20525
R1349 VSS.n117 VSS.t137 0.20525
R1350 VSS.n117 VSS.t135 0.20525
R1351 VSS.n116 VSS.t57 0.20525
R1352 VSS.n116 VSS.t55 0.20525
R1353 VSS.n113 VSS.t203 0.20525
R1354 VSS.n113 VSS.t201 0.20525
R1355 VSS.n111 VSS.t171 0.20525
R1356 VSS.n111 VSS.t169 0.20525
R1357 VSS.n109 VSS.t63 0.20525
R1358 VSS.n109 VSS.t61 0.20525
R1359 VSS.n108 VSS.t95 0.20525
R1360 VSS.n108 VSS.t93 0.20525
R1361 VSS.n105 VSS.t277 0.20525
R1362 VSS.n105 VSS.t103 0.20525
R1363 VSS.n103 VSS.t23 0.20525
R1364 VSS.n103 VSS.t65 0.20525
R1365 VSS.n101 VSS.t139 0.20525
R1366 VSS.n101 VSS.t67 0.20525
R1367 VSS.n100 VSS.t87 0.20525
R1368 VSS.n100 VSS.t85 0.20525
R1369 VSS.n97 VSS.t263 0.20525
R1370 VSS.n97 VSS.t253 0.20525
R1371 VSS.n96 VSS.t257 0.20525
R1372 VSS.n96 VSS.t259 0.20525
R1373 VSS.n93 VSS.t245 0.20525
R1374 VSS.n93 VSS.t247 0.20525
R1375 VSS.n92 VSS.t241 0.20525
R1376 VSS.n92 VSS.t243 0.20525
R1377 VSS.n89 VSS.t255 0.20525
R1378 VSS.n89 VSS.t249 0.20525
R1379 VSS.n88 VSS.t251 0.20525
R1380 VSS.n88 VSS.t261 0.20525
R1381 VSS.n11 VSS.n9 0.189974
R1382 VSS.n13 VSS.n11 0.189974
R1383 VSS.n15 VSS.n13 0.189974
R1384 VSS.n17 VSS.n15 0.189974
R1385 VSS.n19 VSS.n17 0.189974
R1386 VSS.n21 VSS.n19 0.189974
R1387 VSS.n23 VSS.n21 0.189974
R1388 VSS.n25 VSS.n23 0.189974
R1389 VSS.n27 VSS.n25 0.189974
R1390 VSS.n29 VSS.n27 0.189974
R1391 VSS.n31 VSS.n29 0.189974
R1392 VSS.n33 VSS.n31 0.189974
R1393 VSS.n35 VSS.n33 0.189974
R1394 VSS.n37 VSS.n35 0.189974
R1395 VSS.n43 VSS.n41 0.189974
R1396 VSS.n45 VSS.n43 0.189974
R1397 VSS.n47 VSS.n45 0.189974
R1398 VSS.n49 VSS.n47 0.189974
R1399 VSS.n55 VSS.n53 0.189974
R1400 VSS.n57 VSS.n55 0.189974
R1401 VSS.n63 VSS.n61 0.189974
R1402 VSS.n65 VSS.n63 0.189974
R1403 VSS.n132 VSS.n130 0.189974
R1404 VSS.n134 VSS.n132 0.189974
R1405 VSS.n136 VSS.n134 0.189974
R1406 VSS.n138 VSS.n136 0.189974
R1407 VSS.n140 VSS.n138 0.189974
R1408 VSS.n142 VSS.n140 0.189974
R1409 VSS.n144 VSS.n142 0.189974
R1410 VSS.n146 VSS.n144 0.189974
R1411 VSS.n148 VSS.n146 0.189974
R1412 VSS.n150 VSS.n148 0.189974
R1413 VSS.n152 VSS.n150 0.189974
R1414 VSS.n154 VSS.n152 0.189974
R1415 VSS.n156 VSS.n154 0.189974
R1416 VSS.n158 VSS.n156 0.189974
R1417 VSS.n120 VSS.n118 0.189974
R1418 VSS.n122 VSS.n120 0.189974
R1419 VSS.n124 VSS.n122 0.189974
R1420 VSS.n126 VSS.n124 0.189974
R1421 VSS.n112 VSS.n110 0.189974
R1422 VSS.n114 VSS.n112 0.189974
R1423 VSS.n104 VSS.n102 0.189974
R1424 VSS.n106 VSS.n104 0.189974
R1425 VSS.n38 VSS.n6 0.0571608
R1426 VSS.n160 VSS.n159 0.0571608
R1427 VSS.n170 VSS.n0 0.020105
R1428 VSS.n81 VSS.n5 0.00725
R1429 VSS.n79 VSS.n5 0.00725
R1430 VSS.n163 VSS.n87 0.00725
R1431 VSS.n163 VSS.n162 0.00725
R1432 VSS.n169 VSS.n168 0.0054955
R1433 VSS.n169 VSS.n1 0.0054955
R1434 a_14540_6400.n77 a_14540_6400.t55 113.632
R1435 a_14540_6400.n99 a_14540_6400.t24 113.632
R1436 a_14540_6400.n16 a_14540_6400.t87 113.632
R1437 a_14540_6400.n38 a_14540_6400.t56 113.632
R1438 a_14540_6400.n120 a_14540_6400.t39 109.174
R1439 a_14540_6400.n121 a_14540_6400.t40 109.174
R1440 a_14540_6400.n78 a_14540_6400.t54 109.174
R1441 a_14540_6400.n79 a_14540_6400.t53 109.174
R1442 a_14540_6400.n80 a_14540_6400.t52 109.174
R1443 a_14540_6400.n81 a_14540_6400.t51 109.174
R1444 a_14540_6400.n82 a_14540_6400.t50 109.174
R1445 a_14540_6400.n83 a_14540_6400.t49 109.174
R1446 a_14540_6400.n84 a_14540_6400.t48 109.174
R1447 a_14540_6400.n85 a_14540_6400.t47 109.174
R1448 a_14540_6400.n86 a_14540_6400.t46 109.174
R1449 a_14540_6400.n87 a_14540_6400.t45 109.174
R1450 a_14540_6400.n88 a_14540_6400.t44 109.174
R1451 a_14540_6400.n89 a_14540_6400.t43 109.174
R1452 a_14540_6400.n90 a_14540_6400.t42 109.174
R1453 a_14540_6400.n91 a_14540_6400.t41 109.174
R1454 a_14540_6400.n119 a_14540_6400.t38 109.174
R1455 a_14540_6400.n92 a_14540_6400.t37 109.174
R1456 a_14540_6400.n115 a_14540_6400.t36 109.174
R1457 a_14540_6400.n114 a_14540_6400.t35 109.174
R1458 a_14540_6400.n113 a_14540_6400.t34 109.174
R1459 a_14540_6400.n94 a_14540_6400.t33 109.174
R1460 a_14540_6400.n109 a_14540_6400.t32 109.174
R1461 a_14540_6400.n108 a_14540_6400.t31 109.174
R1462 a_14540_6400.n107 a_14540_6400.t30 109.174
R1463 a_14540_6400.n96 a_14540_6400.t29 109.174
R1464 a_14540_6400.n103 a_14540_6400.t28 109.174
R1465 a_14540_6400.n102 a_14540_6400.t27 109.174
R1466 a_14540_6400.n101 a_14540_6400.t26 109.174
R1467 a_14540_6400.n98 a_14540_6400.t25 109.174
R1468 a_14540_6400.n59 a_14540_6400.t71 109.174
R1469 a_14540_6400.n60 a_14540_6400.t72 109.174
R1470 a_14540_6400.n17 a_14540_6400.t86 109.174
R1471 a_14540_6400.n18 a_14540_6400.t85 109.174
R1472 a_14540_6400.n19 a_14540_6400.t84 109.174
R1473 a_14540_6400.n20 a_14540_6400.t83 109.174
R1474 a_14540_6400.n21 a_14540_6400.t82 109.174
R1475 a_14540_6400.n22 a_14540_6400.t81 109.174
R1476 a_14540_6400.n23 a_14540_6400.t80 109.174
R1477 a_14540_6400.n24 a_14540_6400.t79 109.174
R1478 a_14540_6400.n25 a_14540_6400.t78 109.174
R1479 a_14540_6400.n26 a_14540_6400.t77 109.174
R1480 a_14540_6400.n27 a_14540_6400.t76 109.174
R1481 a_14540_6400.n28 a_14540_6400.t75 109.174
R1482 a_14540_6400.n29 a_14540_6400.t74 109.174
R1483 a_14540_6400.n30 a_14540_6400.t73 109.174
R1484 a_14540_6400.n58 a_14540_6400.t70 109.174
R1485 a_14540_6400.n31 a_14540_6400.t69 109.174
R1486 a_14540_6400.n54 a_14540_6400.t68 109.174
R1487 a_14540_6400.n53 a_14540_6400.t67 109.174
R1488 a_14540_6400.n52 a_14540_6400.t66 109.174
R1489 a_14540_6400.n33 a_14540_6400.t65 109.174
R1490 a_14540_6400.n48 a_14540_6400.t64 109.174
R1491 a_14540_6400.n47 a_14540_6400.t63 109.174
R1492 a_14540_6400.n46 a_14540_6400.t62 109.174
R1493 a_14540_6400.n35 a_14540_6400.t61 109.174
R1494 a_14540_6400.n42 a_14540_6400.t60 109.174
R1495 a_14540_6400.n41 a_14540_6400.t59 109.174
R1496 a_14540_6400.n40 a_14540_6400.t58 109.174
R1497 a_14540_6400.n37 a_14540_6400.t57 109.174
R1498 a_14540_6400.n120 a_14540_6400.n63 18.4942
R1499 a_14540_6400.n122 a_14540_6400.n121 18.4942
R1500 a_14540_6400.n79 a_14540_6400.n76 18.4942
R1501 a_14540_6400.n80 a_14540_6400.n75 18.4942
R1502 a_14540_6400.n81 a_14540_6400.n74 18.4942
R1503 a_14540_6400.n82 a_14540_6400.n73 18.4942
R1504 a_14540_6400.n83 a_14540_6400.n72 18.4942
R1505 a_14540_6400.n84 a_14540_6400.n71 18.4942
R1506 a_14540_6400.n85 a_14540_6400.n70 18.4942
R1507 a_14540_6400.n86 a_14540_6400.n69 18.4942
R1508 a_14540_6400.n87 a_14540_6400.n68 18.4942
R1509 a_14540_6400.n88 a_14540_6400.n67 18.4942
R1510 a_14540_6400.n89 a_14540_6400.n66 18.4942
R1511 a_14540_6400.n90 a_14540_6400.n65 18.4942
R1512 a_14540_6400.n91 a_14540_6400.n64 18.4942
R1513 a_14540_6400.n119 a_14540_6400.n118 18.4942
R1514 a_14540_6400.n117 a_14540_6400.n92 18.4942
R1515 a_14540_6400.n116 a_14540_6400.n115 18.4942
R1516 a_14540_6400.n114 a_14540_6400.n93 18.4942
R1517 a_14540_6400.n113 a_14540_6400.n112 18.4942
R1518 a_14540_6400.n111 a_14540_6400.n94 18.4942
R1519 a_14540_6400.n110 a_14540_6400.n109 18.4942
R1520 a_14540_6400.n108 a_14540_6400.n95 18.4942
R1521 a_14540_6400.n107 a_14540_6400.n106 18.4942
R1522 a_14540_6400.n105 a_14540_6400.n96 18.4942
R1523 a_14540_6400.n104 a_14540_6400.n103 18.4942
R1524 a_14540_6400.n102 a_14540_6400.n97 18.4942
R1525 a_14540_6400.n101 a_14540_6400.n100 18.4942
R1526 a_14540_6400.n59 a_14540_6400.n2 18.4942
R1527 a_14540_6400.n61 a_14540_6400.n60 18.4942
R1528 a_14540_6400.n18 a_14540_6400.n15 18.4942
R1529 a_14540_6400.n19 a_14540_6400.n14 18.4942
R1530 a_14540_6400.n20 a_14540_6400.n13 18.4942
R1531 a_14540_6400.n21 a_14540_6400.n12 18.4942
R1532 a_14540_6400.n22 a_14540_6400.n11 18.4942
R1533 a_14540_6400.n23 a_14540_6400.n10 18.4942
R1534 a_14540_6400.n24 a_14540_6400.n9 18.4942
R1535 a_14540_6400.n25 a_14540_6400.n8 18.4942
R1536 a_14540_6400.n26 a_14540_6400.n7 18.4942
R1537 a_14540_6400.n27 a_14540_6400.n6 18.4942
R1538 a_14540_6400.n28 a_14540_6400.n5 18.4942
R1539 a_14540_6400.n29 a_14540_6400.n4 18.4942
R1540 a_14540_6400.n30 a_14540_6400.n3 18.4942
R1541 a_14540_6400.n58 a_14540_6400.n57 18.4942
R1542 a_14540_6400.n56 a_14540_6400.n31 18.4942
R1543 a_14540_6400.n55 a_14540_6400.n54 18.4942
R1544 a_14540_6400.n53 a_14540_6400.n32 18.4942
R1545 a_14540_6400.n52 a_14540_6400.n51 18.4942
R1546 a_14540_6400.n50 a_14540_6400.n33 18.4942
R1547 a_14540_6400.n49 a_14540_6400.n48 18.4942
R1548 a_14540_6400.n47 a_14540_6400.n34 18.4942
R1549 a_14540_6400.n46 a_14540_6400.n45 18.4942
R1550 a_14540_6400.n44 a_14540_6400.n35 18.4942
R1551 a_14540_6400.n43 a_14540_6400.n42 18.4942
R1552 a_14540_6400.n41 a_14540_6400.n36 18.4942
R1553 a_14540_6400.n40 a_14540_6400.n39 18.4942
R1554 a_14540_6400.n136 a_14540_6400.n124 16.0141
R1555 a_14540_6400.n120 a_14540_6400.n119 11.6805
R1556 a_14540_6400.n121 a_14540_6400.n120 11.6805
R1557 a_14540_6400.n79 a_14540_6400.n78 11.6805
R1558 a_14540_6400.n80 a_14540_6400.n79 11.6805
R1559 a_14540_6400.n81 a_14540_6400.n80 11.6805
R1560 a_14540_6400.n82 a_14540_6400.n81 11.6805
R1561 a_14540_6400.n83 a_14540_6400.n82 11.6805
R1562 a_14540_6400.n84 a_14540_6400.n83 11.6805
R1563 a_14540_6400.n85 a_14540_6400.n84 11.6805
R1564 a_14540_6400.n86 a_14540_6400.n85 11.6805
R1565 a_14540_6400.n87 a_14540_6400.n86 11.6805
R1566 a_14540_6400.n88 a_14540_6400.n87 11.6805
R1567 a_14540_6400.n89 a_14540_6400.n88 11.6805
R1568 a_14540_6400.n90 a_14540_6400.n89 11.6805
R1569 a_14540_6400.n91 a_14540_6400.n90 11.6805
R1570 a_14540_6400.n121 a_14540_6400.n91 11.6805
R1571 a_14540_6400.n119 a_14540_6400.n92 11.6805
R1572 a_14540_6400.n115 a_14540_6400.n92 11.6805
R1573 a_14540_6400.n115 a_14540_6400.n114 11.6805
R1574 a_14540_6400.n114 a_14540_6400.n113 11.6805
R1575 a_14540_6400.n113 a_14540_6400.n94 11.6805
R1576 a_14540_6400.n109 a_14540_6400.n94 11.6805
R1577 a_14540_6400.n109 a_14540_6400.n108 11.6805
R1578 a_14540_6400.n108 a_14540_6400.n107 11.6805
R1579 a_14540_6400.n107 a_14540_6400.n96 11.6805
R1580 a_14540_6400.n103 a_14540_6400.n96 11.6805
R1581 a_14540_6400.n103 a_14540_6400.n102 11.6805
R1582 a_14540_6400.n102 a_14540_6400.n101 11.6805
R1583 a_14540_6400.n101 a_14540_6400.n98 11.6805
R1584 a_14540_6400.n59 a_14540_6400.n58 11.6805
R1585 a_14540_6400.n60 a_14540_6400.n59 11.6805
R1586 a_14540_6400.n18 a_14540_6400.n17 11.6805
R1587 a_14540_6400.n19 a_14540_6400.n18 11.6805
R1588 a_14540_6400.n20 a_14540_6400.n19 11.6805
R1589 a_14540_6400.n21 a_14540_6400.n20 11.6805
R1590 a_14540_6400.n22 a_14540_6400.n21 11.6805
R1591 a_14540_6400.n23 a_14540_6400.n22 11.6805
R1592 a_14540_6400.n24 a_14540_6400.n23 11.6805
R1593 a_14540_6400.n25 a_14540_6400.n24 11.6805
R1594 a_14540_6400.n26 a_14540_6400.n25 11.6805
R1595 a_14540_6400.n27 a_14540_6400.n26 11.6805
R1596 a_14540_6400.n28 a_14540_6400.n27 11.6805
R1597 a_14540_6400.n29 a_14540_6400.n28 11.6805
R1598 a_14540_6400.n30 a_14540_6400.n29 11.6805
R1599 a_14540_6400.n60 a_14540_6400.n30 11.6805
R1600 a_14540_6400.n58 a_14540_6400.n31 11.6805
R1601 a_14540_6400.n54 a_14540_6400.n31 11.6805
R1602 a_14540_6400.n54 a_14540_6400.n53 11.6805
R1603 a_14540_6400.n53 a_14540_6400.n52 11.6805
R1604 a_14540_6400.n52 a_14540_6400.n33 11.6805
R1605 a_14540_6400.n48 a_14540_6400.n33 11.6805
R1606 a_14540_6400.n48 a_14540_6400.n47 11.6805
R1607 a_14540_6400.n47 a_14540_6400.n46 11.6805
R1608 a_14540_6400.n46 a_14540_6400.n35 11.6805
R1609 a_14540_6400.n42 a_14540_6400.n35 11.6805
R1610 a_14540_6400.n42 a_14540_6400.n41 11.6805
R1611 a_14540_6400.n41 a_14540_6400.n40 11.6805
R1612 a_14540_6400.n40 a_14540_6400.n37 11.6805
R1613 a_14540_6400.n124 a_14540_6400.n62 10.688
R1614 a_14540_6400.n124 a_14540_6400.n123 9.24157
R1615 a_14540_6400.n100 a_14540_6400.n99 7.17687
R1616 a_14540_6400.n77 a_14540_6400.n76 7.17687
R1617 a_14540_6400.n39 a_14540_6400.n38 7.17687
R1618 a_14540_6400.n16 a_14540_6400.n15 7.17687
R1619 a_14540_6400.n137 a_14540_6400.n136 6.5392
R1620 a_14540_6400.n126 a_14540_6400.t2 5.7796
R1621 a_14540_6400.n1 a_14540_6400.t9 5.73764
R1622 a_14540_6400.n135 a_14540_6400.t6 5.59012
R1623 a_14540_6400.n137 a_14540_6400.t8 5.54817
R1624 a_14540_6400.n126 a_14540_6400.n125 5.38537
R1625 a_14540_6400.n128 a_14540_6400.n127 5.38537
R1626 a_14540_6400.n130 a_14540_6400.n129 5.38537
R1627 a_14540_6400.n132 a_14540_6400.n131 5.38537
R1628 a_14540_6400.n134 a_14540_6400.n133 5.38537
R1629 a_14540_6400.n145 a_14540_6400.n144 5.32067
R1630 a_14540_6400.n1 a_14540_6400.n0 5.32067
R1631 a_14540_6400.n143 a_14540_6400.n142 5.32067
R1632 a_14540_6400.n141 a_14540_6400.n140 5.32067
R1633 a_14540_6400.n139 a_14540_6400.n138 5.32067
R1634 a_14540_6400.n136 a_14540_6400.n135 4.61063
R1635 a_14540_6400.n78 a_14540_6400.n77 4.42851
R1636 a_14540_6400.n99 a_14540_6400.n98 4.42851
R1637 a_14540_6400.n17 a_14540_6400.n16 4.42851
R1638 a_14540_6400.n38 a_14540_6400.n37 4.42851
R1639 a_14540_6400.t0 a_14540_6400.n145 0.228
R1640 a_14540_6400.n145 a_14540_6400.t12 0.228
R1641 a_14540_6400.n0 a_14540_6400.t11 0.228
R1642 a_14540_6400.n0 a_14540_6400.t10 0.228
R1643 a_14540_6400.n142 a_14540_6400.t21 0.228
R1644 a_14540_6400.n142 a_14540_6400.t1 0.228
R1645 a_14540_6400.n140 a_14540_6400.t3 0.228
R1646 a_14540_6400.n140 a_14540_6400.t22 0.228
R1647 a_14540_6400.n138 a_14540_6400.t7 0.228
R1648 a_14540_6400.n138 a_14540_6400.t4 0.228
R1649 a_14540_6400.n125 a_14540_6400.t19 0.20525
R1650 a_14540_6400.n125 a_14540_6400.t23 0.20525
R1651 a_14540_6400.n127 a_14540_6400.t15 0.20525
R1652 a_14540_6400.n127 a_14540_6400.t20 0.20525
R1653 a_14540_6400.n129 a_14540_6400.t17 0.20525
R1654 a_14540_6400.n129 a_14540_6400.t16 0.20525
R1655 a_14540_6400.n131 a_14540_6400.t13 0.20525
R1656 a_14540_6400.n131 a_14540_6400.t18 0.20525
R1657 a_14540_6400.n133 a_14540_6400.t5 0.20525
R1658 a_14540_6400.n133 a_14540_6400.t14 0.20525
R1659 a_14540_6400.n139 a_14540_6400.n137 0.189974
R1660 a_14540_6400.n141 a_14540_6400.n139 0.189974
R1661 a_14540_6400.n143 a_14540_6400.n141 0.189974
R1662 a_14540_6400.n144 a_14540_6400.n143 0.189974
R1663 a_14540_6400.n144 a_14540_6400.n1 0.189974
R1664 a_14540_6400.n135 a_14540_6400.n134 0.189974
R1665 a_14540_6400.n134 a_14540_6400.n132 0.189974
R1666 a_14540_6400.n132 a_14540_6400.n130 0.189974
R1667 a_14540_6400.n130 a_14540_6400.n128 0.189974
R1668 a_14540_6400.n128 a_14540_6400.n126 0.189974
R1669 a_14540_6400.n118 a_14540_6400.n63 0.1205
R1670 a_14540_6400.n118 a_14540_6400.n117 0.1205
R1671 a_14540_6400.n117 a_14540_6400.n116 0.1205
R1672 a_14540_6400.n116 a_14540_6400.n93 0.1205
R1673 a_14540_6400.n112 a_14540_6400.n93 0.1205
R1674 a_14540_6400.n112 a_14540_6400.n111 0.1205
R1675 a_14540_6400.n111 a_14540_6400.n110 0.1205
R1676 a_14540_6400.n110 a_14540_6400.n95 0.1205
R1677 a_14540_6400.n106 a_14540_6400.n95 0.1205
R1678 a_14540_6400.n106 a_14540_6400.n105 0.1205
R1679 a_14540_6400.n105 a_14540_6400.n104 0.1205
R1680 a_14540_6400.n104 a_14540_6400.n97 0.1205
R1681 a_14540_6400.n100 a_14540_6400.n97 0.1205
R1682 a_14540_6400.n76 a_14540_6400.n75 0.1205
R1683 a_14540_6400.n75 a_14540_6400.n74 0.1205
R1684 a_14540_6400.n74 a_14540_6400.n73 0.1205
R1685 a_14540_6400.n73 a_14540_6400.n72 0.1205
R1686 a_14540_6400.n72 a_14540_6400.n71 0.1205
R1687 a_14540_6400.n71 a_14540_6400.n70 0.1205
R1688 a_14540_6400.n70 a_14540_6400.n69 0.1205
R1689 a_14540_6400.n69 a_14540_6400.n68 0.1205
R1690 a_14540_6400.n68 a_14540_6400.n67 0.1205
R1691 a_14540_6400.n67 a_14540_6400.n66 0.1205
R1692 a_14540_6400.n66 a_14540_6400.n65 0.1205
R1693 a_14540_6400.n65 a_14540_6400.n64 0.1205
R1694 a_14540_6400.n122 a_14540_6400.n64 0.1205
R1695 a_14540_6400.n57 a_14540_6400.n2 0.1205
R1696 a_14540_6400.n57 a_14540_6400.n56 0.1205
R1697 a_14540_6400.n56 a_14540_6400.n55 0.1205
R1698 a_14540_6400.n55 a_14540_6400.n32 0.1205
R1699 a_14540_6400.n51 a_14540_6400.n32 0.1205
R1700 a_14540_6400.n51 a_14540_6400.n50 0.1205
R1701 a_14540_6400.n50 a_14540_6400.n49 0.1205
R1702 a_14540_6400.n49 a_14540_6400.n34 0.1205
R1703 a_14540_6400.n45 a_14540_6400.n34 0.1205
R1704 a_14540_6400.n45 a_14540_6400.n44 0.1205
R1705 a_14540_6400.n44 a_14540_6400.n43 0.1205
R1706 a_14540_6400.n43 a_14540_6400.n36 0.1205
R1707 a_14540_6400.n39 a_14540_6400.n36 0.1205
R1708 a_14540_6400.n15 a_14540_6400.n14 0.1205
R1709 a_14540_6400.n14 a_14540_6400.n13 0.1205
R1710 a_14540_6400.n13 a_14540_6400.n12 0.1205
R1711 a_14540_6400.n12 a_14540_6400.n11 0.1205
R1712 a_14540_6400.n11 a_14540_6400.n10 0.1205
R1713 a_14540_6400.n10 a_14540_6400.n9 0.1205
R1714 a_14540_6400.n9 a_14540_6400.n8 0.1205
R1715 a_14540_6400.n8 a_14540_6400.n7 0.1205
R1716 a_14540_6400.n7 a_14540_6400.n6 0.1205
R1717 a_14540_6400.n6 a_14540_6400.n5 0.1205
R1718 a_14540_6400.n5 a_14540_6400.n4 0.1205
R1719 a_14540_6400.n4 a_14540_6400.n3 0.1205
R1720 a_14540_6400.n61 a_14540_6400.n3 0.1205
R1721 a_14540_6400.n123 a_14540_6400.n63 0.0485
R1722 a_14540_6400.n123 a_14540_6400.n122 0.0485
R1723 a_14540_6400.n62 a_14540_6400.n2 0.0485
R1724 a_14540_6400.n62 a_14540_6400.n61 0.0485
R1725 a_6924_6400.n28 a_6924_6400.t19 113.632
R1726 a_6924_6400.n34 a_6924_6400.t8 113.632
R1727 a_6924_6400.n7 a_6924_6400.t31 113.632
R1728 a_6924_6400.n13 a_6924_6400.t20 113.632
R1729 a_6924_6400.n41 a_6924_6400.t13 109.174
R1730 a_6924_6400.n42 a_6924_6400.t14 109.174
R1731 a_6924_6400.n29 a_6924_6400.t18 109.174
R1732 a_6924_6400.n30 a_6924_6400.t17 109.174
R1733 a_6924_6400.n31 a_6924_6400.t16 109.174
R1734 a_6924_6400.n32 a_6924_6400.t15 109.174
R1735 a_6924_6400.n40 a_6924_6400.t12 109.174
R1736 a_6924_6400.n33 a_6924_6400.t11 109.174
R1737 a_6924_6400.n36 a_6924_6400.t10 109.174
R1738 a_6924_6400.n35 a_6924_6400.t9 109.174
R1739 a_6924_6400.n20 a_6924_6400.t25 109.174
R1740 a_6924_6400.n21 a_6924_6400.t26 109.174
R1741 a_6924_6400.n8 a_6924_6400.t30 109.174
R1742 a_6924_6400.n9 a_6924_6400.t29 109.174
R1743 a_6924_6400.n10 a_6924_6400.t28 109.174
R1744 a_6924_6400.n11 a_6924_6400.t27 109.174
R1745 a_6924_6400.n19 a_6924_6400.t24 109.174
R1746 a_6924_6400.n12 a_6924_6400.t23 109.174
R1747 a_6924_6400.n15 a_6924_6400.t22 109.174
R1748 a_6924_6400.n14 a_6924_6400.t21 109.174
R1749 a_6924_6400.n41 a_6924_6400.n24 18.4942
R1750 a_6924_6400.n43 a_6924_6400.n42 18.4942
R1751 a_6924_6400.n30 a_6924_6400.n27 18.4942
R1752 a_6924_6400.n31 a_6924_6400.n26 18.4942
R1753 a_6924_6400.n32 a_6924_6400.n25 18.4942
R1754 a_6924_6400.n40 a_6924_6400.n39 18.4942
R1755 a_6924_6400.n38 a_6924_6400.n33 18.4942
R1756 a_6924_6400.n37 a_6924_6400.n36 18.4942
R1757 a_6924_6400.n20 a_6924_6400.n3 18.4942
R1758 a_6924_6400.n22 a_6924_6400.n21 18.4942
R1759 a_6924_6400.n9 a_6924_6400.n6 18.4942
R1760 a_6924_6400.n10 a_6924_6400.n5 18.4942
R1761 a_6924_6400.n11 a_6924_6400.n4 18.4942
R1762 a_6924_6400.n19 a_6924_6400.n18 18.4942
R1763 a_6924_6400.n17 a_6924_6400.n12 18.4942
R1764 a_6924_6400.n16 a_6924_6400.n15 18.4942
R1765 a_6924_6400.n46 a_6924_6400.n45 17.906
R1766 a_6924_6400.n41 a_6924_6400.n40 11.6805
R1767 a_6924_6400.n42 a_6924_6400.n41 11.6805
R1768 a_6924_6400.n30 a_6924_6400.n29 11.6805
R1769 a_6924_6400.n31 a_6924_6400.n30 11.6805
R1770 a_6924_6400.n32 a_6924_6400.n31 11.6805
R1771 a_6924_6400.n42 a_6924_6400.n32 11.6805
R1772 a_6924_6400.n40 a_6924_6400.n33 11.6805
R1773 a_6924_6400.n36 a_6924_6400.n33 11.6805
R1774 a_6924_6400.n36 a_6924_6400.n35 11.6805
R1775 a_6924_6400.n20 a_6924_6400.n19 11.6805
R1776 a_6924_6400.n21 a_6924_6400.n20 11.6805
R1777 a_6924_6400.n9 a_6924_6400.n8 11.6805
R1778 a_6924_6400.n10 a_6924_6400.n9 11.6805
R1779 a_6924_6400.n11 a_6924_6400.n10 11.6805
R1780 a_6924_6400.n21 a_6924_6400.n11 11.6805
R1781 a_6924_6400.n19 a_6924_6400.n12 11.6805
R1782 a_6924_6400.n15 a_6924_6400.n12 11.6805
R1783 a_6924_6400.n15 a_6924_6400.n14 11.6805
R1784 a_6924_6400.n45 a_6924_6400.n23 10.013
R1785 a_6924_6400.n45 a_6924_6400.n44 9.91657
R1786 a_6924_6400.n37 a_6924_6400.n34 7.17687
R1787 a_6924_6400.n28 a_6924_6400.n27 7.17687
R1788 a_6924_6400.n16 a_6924_6400.n13 7.17687
R1789 a_6924_6400.n7 a_6924_6400.n6 7.17687
R1790 a_6924_6400.n46 a_6924_6400.n2 6.5392
R1791 a_6924_6400.t3 a_6924_6400.n49 5.7796
R1792 a_6924_6400.n1 a_6924_6400.t7 5.73764
R1793 a_6924_6400.n47 a_6924_6400.t0 5.59012
R1794 a_6924_6400.n2 a_6924_6400.t4 5.54817
R1795 a_6924_6400.n49 a_6924_6400.n48 5.38537
R1796 a_6924_6400.n1 a_6924_6400.n0 5.32067
R1797 a_6924_6400.n47 a_6924_6400.n46 4.61063
R1798 a_6924_6400.n29 a_6924_6400.n28 4.42851
R1799 a_6924_6400.n35 a_6924_6400.n34 4.42851
R1800 a_6924_6400.n8 a_6924_6400.n7 4.42851
R1801 a_6924_6400.n14 a_6924_6400.n13 4.42851
R1802 a_6924_6400.n0 a_6924_6400.t5 0.228
R1803 a_6924_6400.n0 a_6924_6400.t6 0.228
R1804 a_6924_6400.n48 a_6924_6400.t1 0.20525
R1805 a_6924_6400.n48 a_6924_6400.t2 0.20525
R1806 a_6924_6400.n49 a_6924_6400.n47 0.189974
R1807 a_6924_6400.n2 a_6924_6400.n1 0.189974
R1808 a_6924_6400.n39 a_6924_6400.n24 0.1205
R1809 a_6924_6400.n39 a_6924_6400.n38 0.1205
R1810 a_6924_6400.n38 a_6924_6400.n37 0.1205
R1811 a_6924_6400.n27 a_6924_6400.n26 0.1205
R1812 a_6924_6400.n26 a_6924_6400.n25 0.1205
R1813 a_6924_6400.n43 a_6924_6400.n25 0.1205
R1814 a_6924_6400.n18 a_6924_6400.n3 0.1205
R1815 a_6924_6400.n18 a_6924_6400.n17 0.1205
R1816 a_6924_6400.n17 a_6924_6400.n16 0.1205
R1817 a_6924_6400.n6 a_6924_6400.n5 0.1205
R1818 a_6924_6400.n5 a_6924_6400.n4 0.1205
R1819 a_6924_6400.n22 a_6924_6400.n4 0.1205
R1820 a_6924_6400.n44 a_6924_6400.n24 0.0485
R1821 a_6924_6400.n44 a_6924_6400.n43 0.0485
R1822 a_6924_6400.n23 a_6924_6400.n3 0.0485
R1823 a_6924_6400.n23 a_6924_6400.n22 0.0485
R1824 a_4812_6400.n18 a_4812_6400.t15 113.632
R1825 a_4812_6400.n22 a_4812_6400.t8 113.632
R1826 a_4812_6400.n5 a_4812_6400.t23 113.632
R1827 a_4812_6400.n9 a_4812_6400.t16 113.632
R1828 a_4812_6400.n25 a_4812_6400.t11 109.174
R1829 a_4812_6400.n26 a_4812_6400.t12 109.174
R1830 a_4812_6400.n19 a_4812_6400.t14 109.174
R1831 a_4812_6400.n20 a_4812_6400.t13 109.174
R1832 a_4812_6400.n24 a_4812_6400.t10 109.174
R1833 a_4812_6400.n21 a_4812_6400.t9 109.174
R1834 a_4812_6400.n12 a_4812_6400.t19 109.174
R1835 a_4812_6400.n13 a_4812_6400.t20 109.174
R1836 a_4812_6400.n6 a_4812_6400.t22 109.174
R1837 a_4812_6400.n7 a_4812_6400.t21 109.174
R1838 a_4812_6400.n11 a_4812_6400.t18 109.174
R1839 a_4812_6400.n8 a_4812_6400.t17 109.174
R1840 a_4812_6400.n25 a_4812_6400.n16 18.4942
R1841 a_4812_6400.n27 a_4812_6400.n26 18.4942
R1842 a_4812_6400.n20 a_4812_6400.n17 18.4942
R1843 a_4812_6400.n24 a_4812_6400.n23 18.4942
R1844 a_4812_6400.n12 a_4812_6400.n3 18.4942
R1845 a_4812_6400.n14 a_4812_6400.n13 18.4942
R1846 a_4812_6400.n7 a_4812_6400.n4 18.4942
R1847 a_4812_6400.n11 a_4812_6400.n10 18.4942
R1848 a_4812_6400.n30 a_4812_6400.n29 17.3044
R1849 a_4812_6400.n25 a_4812_6400.n24 11.6805
R1850 a_4812_6400.n26 a_4812_6400.n25 11.6805
R1851 a_4812_6400.n20 a_4812_6400.n19 11.6805
R1852 a_4812_6400.n26 a_4812_6400.n20 11.6805
R1853 a_4812_6400.n24 a_4812_6400.n21 11.6805
R1854 a_4812_6400.n12 a_4812_6400.n11 11.6805
R1855 a_4812_6400.n13 a_4812_6400.n12 11.6805
R1856 a_4812_6400.n7 a_4812_6400.n6 11.6805
R1857 a_4812_6400.n13 a_4812_6400.n7 11.6805
R1858 a_4812_6400.n11 a_4812_6400.n8 11.6805
R1859 a_4812_6400.n29 a_4812_6400.n15 10.3505
R1860 a_4812_6400.n29 a_4812_6400.n28 9.57907
R1861 a_4812_6400.n23 a_4812_6400.n22 7.17687
R1862 a_4812_6400.n18 a_4812_6400.n17 7.17687
R1863 a_4812_6400.n10 a_4812_6400.n9 7.17687
R1864 a_4812_6400.n5 a_4812_6400.n4 7.17687
R1865 a_4812_6400.n30 a_4812_6400.n2 6.5392
R1866 a_4812_6400.t3 a_4812_6400.n33 5.7796
R1867 a_4812_6400.n1 a_4812_6400.t7 5.73764
R1868 a_4812_6400.n31 a_4812_6400.t0 5.59012
R1869 a_4812_6400.n2 a_4812_6400.t4 5.54817
R1870 a_4812_6400.n33 a_4812_6400.n32 5.38537
R1871 a_4812_6400.n1 a_4812_6400.n0 5.32067
R1872 a_4812_6400.n31 a_4812_6400.n30 4.61063
R1873 a_4812_6400.n19 a_4812_6400.n18 4.42851
R1874 a_4812_6400.n22 a_4812_6400.n21 4.42851
R1875 a_4812_6400.n6 a_4812_6400.n5 4.42851
R1876 a_4812_6400.n9 a_4812_6400.n8 4.42851
R1877 a_4812_6400.n0 a_4812_6400.t5 0.228
R1878 a_4812_6400.n0 a_4812_6400.t6 0.228
R1879 a_4812_6400.n32 a_4812_6400.t1 0.20525
R1880 a_4812_6400.n32 a_4812_6400.t2 0.20525
R1881 a_4812_6400.n33 a_4812_6400.n31 0.189974
R1882 a_4812_6400.n2 a_4812_6400.n1 0.189974
R1883 a_4812_6400.n23 a_4812_6400.n16 0.1205
R1884 a_4812_6400.n27 a_4812_6400.n17 0.1205
R1885 a_4812_6400.n10 a_4812_6400.n3 0.1205
R1886 a_4812_6400.n14 a_4812_6400.n4 0.1205
R1887 a_4812_6400.n28 a_4812_6400.n16 0.0485
R1888 a_4812_6400.n28 a_4812_6400.n27 0.0485
R1889 a_4812_6400.n15 a_4812_6400.n3 0.0485
R1890 a_4812_6400.n15 a_4812_6400.n14 0.0485
R1891 a_2700_6400.n18 a_2700_6400.t15 113.632
R1892 a_2700_6400.n22 a_2700_6400.t8 113.632
R1893 a_2700_6400.n5 a_2700_6400.t23 113.632
R1894 a_2700_6400.n9 a_2700_6400.t16 113.632
R1895 a_2700_6400.n25 a_2700_6400.t11 109.174
R1896 a_2700_6400.n26 a_2700_6400.t12 109.174
R1897 a_2700_6400.n19 a_2700_6400.t14 109.174
R1898 a_2700_6400.n20 a_2700_6400.t13 109.174
R1899 a_2700_6400.n24 a_2700_6400.t10 109.174
R1900 a_2700_6400.n21 a_2700_6400.t9 109.174
R1901 a_2700_6400.n12 a_2700_6400.t19 109.174
R1902 a_2700_6400.n13 a_2700_6400.t20 109.174
R1903 a_2700_6400.n6 a_2700_6400.t22 109.174
R1904 a_2700_6400.n7 a_2700_6400.t21 109.174
R1905 a_2700_6400.n11 a_2700_6400.t18 109.174
R1906 a_2700_6400.n8 a_2700_6400.t17 109.174
R1907 a_2700_6400.n25 a_2700_6400.n16 18.4942
R1908 a_2700_6400.n27 a_2700_6400.n26 18.4942
R1909 a_2700_6400.n20 a_2700_6400.n17 18.4942
R1910 a_2700_6400.n24 a_2700_6400.n23 18.4942
R1911 a_2700_6400.n12 a_2700_6400.n3 18.4942
R1912 a_2700_6400.n14 a_2700_6400.n13 18.4942
R1913 a_2700_6400.n7 a_2700_6400.n4 18.4942
R1914 a_2700_6400.n11 a_2700_6400.n10 18.4942
R1915 a_2700_6400.n30 a_2700_6400.n29 17.0158
R1916 a_2700_6400.n25 a_2700_6400.n24 11.6805
R1917 a_2700_6400.n26 a_2700_6400.n25 11.6805
R1918 a_2700_6400.n20 a_2700_6400.n19 11.6805
R1919 a_2700_6400.n26 a_2700_6400.n20 11.6805
R1920 a_2700_6400.n24 a_2700_6400.n21 11.6805
R1921 a_2700_6400.n12 a_2700_6400.n11 11.6805
R1922 a_2700_6400.n13 a_2700_6400.n12 11.6805
R1923 a_2700_6400.n7 a_2700_6400.n6 11.6805
R1924 a_2700_6400.n13 a_2700_6400.n7 11.6805
R1925 a_2700_6400.n11 a_2700_6400.n8 11.6805
R1926 a_2700_6400.n29 a_2700_6400.n15 10.688
R1927 a_2700_6400.n29 a_2700_6400.n28 9.24157
R1928 a_2700_6400.n23 a_2700_6400.n22 7.17687
R1929 a_2700_6400.n18 a_2700_6400.n17 7.17687
R1930 a_2700_6400.n10 a_2700_6400.n9 7.17687
R1931 a_2700_6400.n5 a_2700_6400.n4 7.17687
R1932 a_2700_6400.n30 a_2700_6400.n2 6.5392
R1933 a_2700_6400.t3 a_2700_6400.n33 5.7796
R1934 a_2700_6400.n1 a_2700_6400.t7 5.73764
R1935 a_2700_6400.n31 a_2700_6400.t0 5.59012
R1936 a_2700_6400.n2 a_2700_6400.t4 5.54817
R1937 a_2700_6400.n33 a_2700_6400.n32 5.38537
R1938 a_2700_6400.n1 a_2700_6400.n0 5.32067
R1939 a_2700_6400.n31 a_2700_6400.n30 4.61063
R1940 a_2700_6400.n19 a_2700_6400.n18 4.42851
R1941 a_2700_6400.n22 a_2700_6400.n21 4.42851
R1942 a_2700_6400.n6 a_2700_6400.n5 4.42851
R1943 a_2700_6400.n9 a_2700_6400.n8 4.42851
R1944 a_2700_6400.n0 a_2700_6400.t5 0.228
R1945 a_2700_6400.n0 a_2700_6400.t6 0.228
R1946 a_2700_6400.n32 a_2700_6400.t1 0.20525
R1947 a_2700_6400.n32 a_2700_6400.t2 0.20525
R1948 a_2700_6400.n33 a_2700_6400.n31 0.189974
R1949 a_2700_6400.n2 a_2700_6400.n1 0.189974
R1950 a_2700_6400.n23 a_2700_6400.n16 0.1205
R1951 a_2700_6400.n27 a_2700_6400.n17 0.1205
R1952 a_2700_6400.n10 a_2700_6400.n3 0.1205
R1953 a_2700_6400.n14 a_2700_6400.n4 0.1205
R1954 a_2700_6400.n28 a_2700_6400.n16 0.0485
R1955 a_2700_6400.n28 a_2700_6400.n27 0.0485
R1956 a_2700_6400.n15 a_2700_6400.n3 0.0485
R1957 a_2700_6400.n15 a_2700_6400.n14 0.0485
R1958 a_14540_41600.n83 a_14540_41600.t55 113.632
R1959 a_14540_41600.n105 a_14540_41600.t24 113.632
R1960 a_14540_41600.n22 a_14540_41600.t87 113.632
R1961 a_14540_41600.n44 a_14540_41600.t56 113.632
R1962 a_14540_41600.n126 a_14540_41600.t39 109.174
R1963 a_14540_41600.n127 a_14540_41600.t40 109.174
R1964 a_14540_41600.n84 a_14540_41600.t54 109.174
R1965 a_14540_41600.n85 a_14540_41600.t53 109.174
R1966 a_14540_41600.n86 a_14540_41600.t52 109.174
R1967 a_14540_41600.n87 a_14540_41600.t51 109.174
R1968 a_14540_41600.n88 a_14540_41600.t50 109.174
R1969 a_14540_41600.n89 a_14540_41600.t49 109.174
R1970 a_14540_41600.n90 a_14540_41600.t48 109.174
R1971 a_14540_41600.n91 a_14540_41600.t47 109.174
R1972 a_14540_41600.n92 a_14540_41600.t46 109.174
R1973 a_14540_41600.n93 a_14540_41600.t45 109.174
R1974 a_14540_41600.n94 a_14540_41600.t44 109.174
R1975 a_14540_41600.n95 a_14540_41600.t43 109.174
R1976 a_14540_41600.n96 a_14540_41600.t42 109.174
R1977 a_14540_41600.n97 a_14540_41600.t41 109.174
R1978 a_14540_41600.n125 a_14540_41600.t38 109.174
R1979 a_14540_41600.n98 a_14540_41600.t37 109.174
R1980 a_14540_41600.n121 a_14540_41600.t36 109.174
R1981 a_14540_41600.n120 a_14540_41600.t35 109.174
R1982 a_14540_41600.n119 a_14540_41600.t34 109.174
R1983 a_14540_41600.n100 a_14540_41600.t33 109.174
R1984 a_14540_41600.n115 a_14540_41600.t32 109.174
R1985 a_14540_41600.n114 a_14540_41600.t31 109.174
R1986 a_14540_41600.n113 a_14540_41600.t30 109.174
R1987 a_14540_41600.n102 a_14540_41600.t29 109.174
R1988 a_14540_41600.n109 a_14540_41600.t28 109.174
R1989 a_14540_41600.n108 a_14540_41600.t27 109.174
R1990 a_14540_41600.n107 a_14540_41600.t26 109.174
R1991 a_14540_41600.n104 a_14540_41600.t25 109.174
R1992 a_14540_41600.n65 a_14540_41600.t71 109.174
R1993 a_14540_41600.n66 a_14540_41600.t72 109.174
R1994 a_14540_41600.n23 a_14540_41600.t86 109.174
R1995 a_14540_41600.n24 a_14540_41600.t85 109.174
R1996 a_14540_41600.n25 a_14540_41600.t84 109.174
R1997 a_14540_41600.n26 a_14540_41600.t83 109.174
R1998 a_14540_41600.n27 a_14540_41600.t82 109.174
R1999 a_14540_41600.n28 a_14540_41600.t81 109.174
R2000 a_14540_41600.n29 a_14540_41600.t80 109.174
R2001 a_14540_41600.n30 a_14540_41600.t79 109.174
R2002 a_14540_41600.n31 a_14540_41600.t78 109.174
R2003 a_14540_41600.n32 a_14540_41600.t77 109.174
R2004 a_14540_41600.n33 a_14540_41600.t76 109.174
R2005 a_14540_41600.n34 a_14540_41600.t75 109.174
R2006 a_14540_41600.n35 a_14540_41600.t74 109.174
R2007 a_14540_41600.n36 a_14540_41600.t73 109.174
R2008 a_14540_41600.n64 a_14540_41600.t70 109.174
R2009 a_14540_41600.n37 a_14540_41600.t69 109.174
R2010 a_14540_41600.n60 a_14540_41600.t68 109.174
R2011 a_14540_41600.n59 a_14540_41600.t67 109.174
R2012 a_14540_41600.n58 a_14540_41600.t66 109.174
R2013 a_14540_41600.n39 a_14540_41600.t65 109.174
R2014 a_14540_41600.n54 a_14540_41600.t64 109.174
R2015 a_14540_41600.n53 a_14540_41600.t63 109.174
R2016 a_14540_41600.n52 a_14540_41600.t62 109.174
R2017 a_14540_41600.n41 a_14540_41600.t61 109.174
R2018 a_14540_41600.n48 a_14540_41600.t60 109.174
R2019 a_14540_41600.n47 a_14540_41600.t59 109.174
R2020 a_14540_41600.n46 a_14540_41600.t58 109.174
R2021 a_14540_41600.n43 a_14540_41600.t57 109.174
R2022 a_14540_41600.n126 a_14540_41600.n69 18.4942
R2023 a_14540_41600.n128 a_14540_41600.n127 18.4942
R2024 a_14540_41600.n85 a_14540_41600.n82 18.4942
R2025 a_14540_41600.n86 a_14540_41600.n81 18.4942
R2026 a_14540_41600.n87 a_14540_41600.n80 18.4942
R2027 a_14540_41600.n88 a_14540_41600.n79 18.4942
R2028 a_14540_41600.n89 a_14540_41600.n78 18.4942
R2029 a_14540_41600.n90 a_14540_41600.n77 18.4942
R2030 a_14540_41600.n91 a_14540_41600.n76 18.4942
R2031 a_14540_41600.n92 a_14540_41600.n75 18.4942
R2032 a_14540_41600.n93 a_14540_41600.n74 18.4942
R2033 a_14540_41600.n94 a_14540_41600.n73 18.4942
R2034 a_14540_41600.n95 a_14540_41600.n72 18.4942
R2035 a_14540_41600.n96 a_14540_41600.n71 18.4942
R2036 a_14540_41600.n97 a_14540_41600.n70 18.4942
R2037 a_14540_41600.n125 a_14540_41600.n124 18.4942
R2038 a_14540_41600.n123 a_14540_41600.n98 18.4942
R2039 a_14540_41600.n122 a_14540_41600.n121 18.4942
R2040 a_14540_41600.n120 a_14540_41600.n99 18.4942
R2041 a_14540_41600.n119 a_14540_41600.n118 18.4942
R2042 a_14540_41600.n117 a_14540_41600.n100 18.4942
R2043 a_14540_41600.n116 a_14540_41600.n115 18.4942
R2044 a_14540_41600.n114 a_14540_41600.n101 18.4942
R2045 a_14540_41600.n113 a_14540_41600.n112 18.4942
R2046 a_14540_41600.n111 a_14540_41600.n102 18.4942
R2047 a_14540_41600.n110 a_14540_41600.n109 18.4942
R2048 a_14540_41600.n108 a_14540_41600.n103 18.4942
R2049 a_14540_41600.n107 a_14540_41600.n106 18.4942
R2050 a_14540_41600.n65 a_14540_41600.n8 18.4942
R2051 a_14540_41600.n67 a_14540_41600.n66 18.4942
R2052 a_14540_41600.n24 a_14540_41600.n21 18.4942
R2053 a_14540_41600.n25 a_14540_41600.n20 18.4942
R2054 a_14540_41600.n26 a_14540_41600.n19 18.4942
R2055 a_14540_41600.n27 a_14540_41600.n18 18.4942
R2056 a_14540_41600.n28 a_14540_41600.n17 18.4942
R2057 a_14540_41600.n29 a_14540_41600.n16 18.4942
R2058 a_14540_41600.n30 a_14540_41600.n15 18.4942
R2059 a_14540_41600.n31 a_14540_41600.n14 18.4942
R2060 a_14540_41600.n32 a_14540_41600.n13 18.4942
R2061 a_14540_41600.n33 a_14540_41600.n12 18.4942
R2062 a_14540_41600.n34 a_14540_41600.n11 18.4942
R2063 a_14540_41600.n35 a_14540_41600.n10 18.4942
R2064 a_14540_41600.n36 a_14540_41600.n9 18.4942
R2065 a_14540_41600.n64 a_14540_41600.n63 18.4942
R2066 a_14540_41600.n62 a_14540_41600.n37 18.4942
R2067 a_14540_41600.n61 a_14540_41600.n60 18.4942
R2068 a_14540_41600.n59 a_14540_41600.n38 18.4942
R2069 a_14540_41600.n58 a_14540_41600.n57 18.4942
R2070 a_14540_41600.n56 a_14540_41600.n39 18.4942
R2071 a_14540_41600.n55 a_14540_41600.n54 18.4942
R2072 a_14540_41600.n53 a_14540_41600.n40 18.4942
R2073 a_14540_41600.n52 a_14540_41600.n51 18.4942
R2074 a_14540_41600.n50 a_14540_41600.n41 18.4942
R2075 a_14540_41600.n49 a_14540_41600.n48 18.4942
R2076 a_14540_41600.n47 a_14540_41600.n42 18.4942
R2077 a_14540_41600.n46 a_14540_41600.n45 18.4942
R2078 a_14540_41600.n142 a_14540_41600.n130 16.0141
R2079 a_14540_41600.n126 a_14540_41600.n125 11.6805
R2080 a_14540_41600.n127 a_14540_41600.n126 11.6805
R2081 a_14540_41600.n85 a_14540_41600.n84 11.6805
R2082 a_14540_41600.n86 a_14540_41600.n85 11.6805
R2083 a_14540_41600.n87 a_14540_41600.n86 11.6805
R2084 a_14540_41600.n88 a_14540_41600.n87 11.6805
R2085 a_14540_41600.n89 a_14540_41600.n88 11.6805
R2086 a_14540_41600.n90 a_14540_41600.n89 11.6805
R2087 a_14540_41600.n91 a_14540_41600.n90 11.6805
R2088 a_14540_41600.n92 a_14540_41600.n91 11.6805
R2089 a_14540_41600.n93 a_14540_41600.n92 11.6805
R2090 a_14540_41600.n94 a_14540_41600.n93 11.6805
R2091 a_14540_41600.n95 a_14540_41600.n94 11.6805
R2092 a_14540_41600.n96 a_14540_41600.n95 11.6805
R2093 a_14540_41600.n97 a_14540_41600.n96 11.6805
R2094 a_14540_41600.n127 a_14540_41600.n97 11.6805
R2095 a_14540_41600.n125 a_14540_41600.n98 11.6805
R2096 a_14540_41600.n121 a_14540_41600.n98 11.6805
R2097 a_14540_41600.n121 a_14540_41600.n120 11.6805
R2098 a_14540_41600.n120 a_14540_41600.n119 11.6805
R2099 a_14540_41600.n119 a_14540_41600.n100 11.6805
R2100 a_14540_41600.n115 a_14540_41600.n100 11.6805
R2101 a_14540_41600.n115 a_14540_41600.n114 11.6805
R2102 a_14540_41600.n114 a_14540_41600.n113 11.6805
R2103 a_14540_41600.n113 a_14540_41600.n102 11.6805
R2104 a_14540_41600.n109 a_14540_41600.n102 11.6805
R2105 a_14540_41600.n109 a_14540_41600.n108 11.6805
R2106 a_14540_41600.n108 a_14540_41600.n107 11.6805
R2107 a_14540_41600.n107 a_14540_41600.n104 11.6805
R2108 a_14540_41600.n65 a_14540_41600.n64 11.6805
R2109 a_14540_41600.n66 a_14540_41600.n65 11.6805
R2110 a_14540_41600.n24 a_14540_41600.n23 11.6805
R2111 a_14540_41600.n25 a_14540_41600.n24 11.6805
R2112 a_14540_41600.n26 a_14540_41600.n25 11.6805
R2113 a_14540_41600.n27 a_14540_41600.n26 11.6805
R2114 a_14540_41600.n28 a_14540_41600.n27 11.6805
R2115 a_14540_41600.n29 a_14540_41600.n28 11.6805
R2116 a_14540_41600.n30 a_14540_41600.n29 11.6805
R2117 a_14540_41600.n31 a_14540_41600.n30 11.6805
R2118 a_14540_41600.n32 a_14540_41600.n31 11.6805
R2119 a_14540_41600.n33 a_14540_41600.n32 11.6805
R2120 a_14540_41600.n34 a_14540_41600.n33 11.6805
R2121 a_14540_41600.n35 a_14540_41600.n34 11.6805
R2122 a_14540_41600.n36 a_14540_41600.n35 11.6805
R2123 a_14540_41600.n66 a_14540_41600.n36 11.6805
R2124 a_14540_41600.n64 a_14540_41600.n37 11.6805
R2125 a_14540_41600.n60 a_14540_41600.n37 11.6805
R2126 a_14540_41600.n60 a_14540_41600.n59 11.6805
R2127 a_14540_41600.n59 a_14540_41600.n58 11.6805
R2128 a_14540_41600.n58 a_14540_41600.n39 11.6805
R2129 a_14540_41600.n54 a_14540_41600.n39 11.6805
R2130 a_14540_41600.n54 a_14540_41600.n53 11.6805
R2131 a_14540_41600.n53 a_14540_41600.n52 11.6805
R2132 a_14540_41600.n52 a_14540_41600.n41 11.6805
R2133 a_14540_41600.n48 a_14540_41600.n41 11.6805
R2134 a_14540_41600.n48 a_14540_41600.n47 11.6805
R2135 a_14540_41600.n47 a_14540_41600.n46 11.6805
R2136 a_14540_41600.n46 a_14540_41600.n43 11.6805
R2137 a_14540_41600.n130 a_14540_41600.n68 10.688
R2138 a_14540_41600.n130 a_14540_41600.n129 9.24157
R2139 a_14540_41600.n106 a_14540_41600.n105 7.17687
R2140 a_14540_41600.n83 a_14540_41600.n82 7.17687
R2141 a_14540_41600.n45 a_14540_41600.n44 7.17687
R2142 a_14540_41600.n22 a_14540_41600.n21 7.17687
R2143 a_14540_41600.n143 a_14540_41600.n142 6.5392
R2144 a_14540_41600.n132 a_14540_41600.t21 5.7796
R2145 a_14540_41600.n1 a_14540_41600.t15 5.73764
R2146 a_14540_41600.n141 a_14540_41600.t3 5.59012
R2147 a_14540_41600.n143 a_14540_41600.t1 5.54817
R2148 a_14540_41600.n132 a_14540_41600.n131 5.38537
R2149 a_14540_41600.n134 a_14540_41600.n133 5.38537
R2150 a_14540_41600.n136 a_14540_41600.n135 5.38537
R2151 a_14540_41600.n138 a_14540_41600.n137 5.38537
R2152 a_14540_41600.n140 a_14540_41600.n139 5.38537
R2153 a_14540_41600.n145 a_14540_41600.n144 5.32067
R2154 a_14540_41600.n1 a_14540_41600.n0 5.32067
R2155 a_14540_41600.n3 a_14540_41600.n2 5.32067
R2156 a_14540_41600.n5 a_14540_41600.n4 5.32067
R2157 a_14540_41600.n7 a_14540_41600.n6 5.32067
R2158 a_14540_41600.n142 a_14540_41600.n141 4.61063
R2159 a_14540_41600.n84 a_14540_41600.n83 4.42851
R2160 a_14540_41600.n105 a_14540_41600.n104 4.42851
R2161 a_14540_41600.n23 a_14540_41600.n22 4.42851
R2162 a_14540_41600.n44 a_14540_41600.n43 4.42851
R2163 a_14540_41600.t0 a_14540_41600.n145 0.228
R2164 a_14540_41600.n145 a_14540_41600.t8 0.228
R2165 a_14540_41600.n0 a_14540_41600.t17 0.228
R2166 a_14540_41600.n0 a_14540_41600.t16 0.228
R2167 a_14540_41600.n2 a_14540_41600.t19 0.228
R2168 a_14540_41600.n2 a_14540_41600.t18 0.228
R2169 a_14540_41600.n4 a_14540_41600.t22 0.228
R2170 a_14540_41600.n4 a_14540_41600.t20 0.228
R2171 a_14540_41600.n6 a_14540_41600.t7 0.228
R2172 a_14540_41600.n6 a_14540_41600.t23 0.228
R2173 a_14540_41600.n131 a_14540_41600.t5 0.20525
R2174 a_14540_41600.n131 a_14540_41600.t4 0.20525
R2175 a_14540_41600.n133 a_14540_41600.t13 0.20525
R2176 a_14540_41600.n133 a_14540_41600.t6 0.20525
R2177 a_14540_41600.n135 a_14540_41600.t11 0.20525
R2178 a_14540_41600.n135 a_14540_41600.t14 0.20525
R2179 a_14540_41600.n137 a_14540_41600.t9 0.20525
R2180 a_14540_41600.n137 a_14540_41600.t12 0.20525
R2181 a_14540_41600.n139 a_14540_41600.t2 0.20525
R2182 a_14540_41600.n139 a_14540_41600.t10 0.20525
R2183 a_14540_41600.n144 a_14540_41600.n143 0.189974
R2184 a_14540_41600.n144 a_14540_41600.n7 0.189974
R2185 a_14540_41600.n7 a_14540_41600.n5 0.189974
R2186 a_14540_41600.n5 a_14540_41600.n3 0.189974
R2187 a_14540_41600.n3 a_14540_41600.n1 0.189974
R2188 a_14540_41600.n141 a_14540_41600.n140 0.189974
R2189 a_14540_41600.n140 a_14540_41600.n138 0.189974
R2190 a_14540_41600.n138 a_14540_41600.n136 0.189974
R2191 a_14540_41600.n136 a_14540_41600.n134 0.189974
R2192 a_14540_41600.n134 a_14540_41600.n132 0.189974
R2193 a_14540_41600.n124 a_14540_41600.n69 0.1205
R2194 a_14540_41600.n124 a_14540_41600.n123 0.1205
R2195 a_14540_41600.n123 a_14540_41600.n122 0.1205
R2196 a_14540_41600.n122 a_14540_41600.n99 0.1205
R2197 a_14540_41600.n118 a_14540_41600.n99 0.1205
R2198 a_14540_41600.n118 a_14540_41600.n117 0.1205
R2199 a_14540_41600.n117 a_14540_41600.n116 0.1205
R2200 a_14540_41600.n116 a_14540_41600.n101 0.1205
R2201 a_14540_41600.n112 a_14540_41600.n101 0.1205
R2202 a_14540_41600.n112 a_14540_41600.n111 0.1205
R2203 a_14540_41600.n111 a_14540_41600.n110 0.1205
R2204 a_14540_41600.n110 a_14540_41600.n103 0.1205
R2205 a_14540_41600.n106 a_14540_41600.n103 0.1205
R2206 a_14540_41600.n82 a_14540_41600.n81 0.1205
R2207 a_14540_41600.n81 a_14540_41600.n80 0.1205
R2208 a_14540_41600.n80 a_14540_41600.n79 0.1205
R2209 a_14540_41600.n79 a_14540_41600.n78 0.1205
R2210 a_14540_41600.n78 a_14540_41600.n77 0.1205
R2211 a_14540_41600.n77 a_14540_41600.n76 0.1205
R2212 a_14540_41600.n76 a_14540_41600.n75 0.1205
R2213 a_14540_41600.n75 a_14540_41600.n74 0.1205
R2214 a_14540_41600.n74 a_14540_41600.n73 0.1205
R2215 a_14540_41600.n73 a_14540_41600.n72 0.1205
R2216 a_14540_41600.n72 a_14540_41600.n71 0.1205
R2217 a_14540_41600.n71 a_14540_41600.n70 0.1205
R2218 a_14540_41600.n128 a_14540_41600.n70 0.1205
R2219 a_14540_41600.n63 a_14540_41600.n8 0.1205
R2220 a_14540_41600.n63 a_14540_41600.n62 0.1205
R2221 a_14540_41600.n62 a_14540_41600.n61 0.1205
R2222 a_14540_41600.n61 a_14540_41600.n38 0.1205
R2223 a_14540_41600.n57 a_14540_41600.n38 0.1205
R2224 a_14540_41600.n57 a_14540_41600.n56 0.1205
R2225 a_14540_41600.n56 a_14540_41600.n55 0.1205
R2226 a_14540_41600.n55 a_14540_41600.n40 0.1205
R2227 a_14540_41600.n51 a_14540_41600.n40 0.1205
R2228 a_14540_41600.n51 a_14540_41600.n50 0.1205
R2229 a_14540_41600.n50 a_14540_41600.n49 0.1205
R2230 a_14540_41600.n49 a_14540_41600.n42 0.1205
R2231 a_14540_41600.n45 a_14540_41600.n42 0.1205
R2232 a_14540_41600.n21 a_14540_41600.n20 0.1205
R2233 a_14540_41600.n20 a_14540_41600.n19 0.1205
R2234 a_14540_41600.n19 a_14540_41600.n18 0.1205
R2235 a_14540_41600.n18 a_14540_41600.n17 0.1205
R2236 a_14540_41600.n17 a_14540_41600.n16 0.1205
R2237 a_14540_41600.n16 a_14540_41600.n15 0.1205
R2238 a_14540_41600.n15 a_14540_41600.n14 0.1205
R2239 a_14540_41600.n14 a_14540_41600.n13 0.1205
R2240 a_14540_41600.n13 a_14540_41600.n12 0.1205
R2241 a_14540_41600.n12 a_14540_41600.n11 0.1205
R2242 a_14540_41600.n11 a_14540_41600.n10 0.1205
R2243 a_14540_41600.n10 a_14540_41600.n9 0.1205
R2244 a_14540_41600.n67 a_14540_41600.n9 0.1205
R2245 a_14540_41600.n129 a_14540_41600.n69 0.0485
R2246 a_14540_41600.n129 a_14540_41600.n128 0.0485
R2247 a_14540_41600.n68 a_14540_41600.n8 0.0485
R2248 a_14540_41600.n68 a_14540_41600.n67 0.0485
R2249 a_6924_41600.n28 a_6924_41600.t19 113.632
R2250 a_6924_41600.n34 a_6924_41600.t8 113.632
R2251 a_6924_41600.n7 a_6924_41600.t31 113.632
R2252 a_6924_41600.n13 a_6924_41600.t20 113.632
R2253 a_6924_41600.n41 a_6924_41600.t13 109.174
R2254 a_6924_41600.n42 a_6924_41600.t14 109.174
R2255 a_6924_41600.n29 a_6924_41600.t18 109.174
R2256 a_6924_41600.n30 a_6924_41600.t17 109.174
R2257 a_6924_41600.n31 a_6924_41600.t16 109.174
R2258 a_6924_41600.n32 a_6924_41600.t15 109.174
R2259 a_6924_41600.n40 a_6924_41600.t12 109.174
R2260 a_6924_41600.n33 a_6924_41600.t11 109.174
R2261 a_6924_41600.n36 a_6924_41600.t10 109.174
R2262 a_6924_41600.n35 a_6924_41600.t9 109.174
R2263 a_6924_41600.n20 a_6924_41600.t25 109.174
R2264 a_6924_41600.n21 a_6924_41600.t26 109.174
R2265 a_6924_41600.n8 a_6924_41600.t30 109.174
R2266 a_6924_41600.n9 a_6924_41600.t29 109.174
R2267 a_6924_41600.n10 a_6924_41600.t28 109.174
R2268 a_6924_41600.n11 a_6924_41600.t27 109.174
R2269 a_6924_41600.n19 a_6924_41600.t24 109.174
R2270 a_6924_41600.n12 a_6924_41600.t23 109.174
R2271 a_6924_41600.n15 a_6924_41600.t22 109.174
R2272 a_6924_41600.n14 a_6924_41600.t21 109.174
R2273 a_6924_41600.n41 a_6924_41600.n24 18.4942
R2274 a_6924_41600.n43 a_6924_41600.n42 18.4942
R2275 a_6924_41600.n30 a_6924_41600.n27 18.4942
R2276 a_6924_41600.n31 a_6924_41600.n26 18.4942
R2277 a_6924_41600.n32 a_6924_41600.n25 18.4942
R2278 a_6924_41600.n40 a_6924_41600.n39 18.4942
R2279 a_6924_41600.n38 a_6924_41600.n33 18.4942
R2280 a_6924_41600.n37 a_6924_41600.n36 18.4942
R2281 a_6924_41600.n20 a_6924_41600.n3 18.4942
R2282 a_6924_41600.n22 a_6924_41600.n21 18.4942
R2283 a_6924_41600.n9 a_6924_41600.n6 18.4942
R2284 a_6924_41600.n10 a_6924_41600.n5 18.4942
R2285 a_6924_41600.n11 a_6924_41600.n4 18.4942
R2286 a_6924_41600.n19 a_6924_41600.n18 18.4942
R2287 a_6924_41600.n17 a_6924_41600.n12 18.4942
R2288 a_6924_41600.n16 a_6924_41600.n15 18.4942
R2289 a_6924_41600.n46 a_6924_41600.n45 17.906
R2290 a_6924_41600.n41 a_6924_41600.n40 11.6805
R2291 a_6924_41600.n42 a_6924_41600.n41 11.6805
R2292 a_6924_41600.n30 a_6924_41600.n29 11.6805
R2293 a_6924_41600.n31 a_6924_41600.n30 11.6805
R2294 a_6924_41600.n32 a_6924_41600.n31 11.6805
R2295 a_6924_41600.n42 a_6924_41600.n32 11.6805
R2296 a_6924_41600.n40 a_6924_41600.n33 11.6805
R2297 a_6924_41600.n36 a_6924_41600.n33 11.6805
R2298 a_6924_41600.n36 a_6924_41600.n35 11.6805
R2299 a_6924_41600.n20 a_6924_41600.n19 11.6805
R2300 a_6924_41600.n21 a_6924_41600.n20 11.6805
R2301 a_6924_41600.n9 a_6924_41600.n8 11.6805
R2302 a_6924_41600.n10 a_6924_41600.n9 11.6805
R2303 a_6924_41600.n11 a_6924_41600.n10 11.6805
R2304 a_6924_41600.n21 a_6924_41600.n11 11.6805
R2305 a_6924_41600.n19 a_6924_41600.n12 11.6805
R2306 a_6924_41600.n15 a_6924_41600.n12 11.6805
R2307 a_6924_41600.n15 a_6924_41600.n14 11.6805
R2308 a_6924_41600.n45 a_6924_41600.n23 10.013
R2309 a_6924_41600.n45 a_6924_41600.n44 9.91657
R2310 a_6924_41600.n37 a_6924_41600.n34 7.17687
R2311 a_6924_41600.n28 a_6924_41600.n27 7.17687
R2312 a_6924_41600.n16 a_6924_41600.n13 7.17687
R2313 a_6924_41600.n7 a_6924_41600.n6 7.17687
R2314 a_6924_41600.n46 a_6924_41600.n2 6.5392
R2315 a_6924_41600.t3 a_6924_41600.n49 5.7796
R2316 a_6924_41600.n1 a_6924_41600.t7 5.73764
R2317 a_6924_41600.n47 a_6924_41600.t0 5.59012
R2318 a_6924_41600.n2 a_6924_41600.t4 5.54817
R2319 a_6924_41600.n49 a_6924_41600.n48 5.38537
R2320 a_6924_41600.n1 a_6924_41600.n0 5.32067
R2321 a_6924_41600.n47 a_6924_41600.n46 4.61063
R2322 a_6924_41600.n29 a_6924_41600.n28 4.42851
R2323 a_6924_41600.n35 a_6924_41600.n34 4.42851
R2324 a_6924_41600.n8 a_6924_41600.n7 4.42851
R2325 a_6924_41600.n14 a_6924_41600.n13 4.42851
R2326 a_6924_41600.n0 a_6924_41600.t5 0.228
R2327 a_6924_41600.n0 a_6924_41600.t6 0.228
R2328 a_6924_41600.n48 a_6924_41600.t1 0.20525
R2329 a_6924_41600.n48 a_6924_41600.t2 0.20525
R2330 a_6924_41600.n49 a_6924_41600.n47 0.189974
R2331 a_6924_41600.n2 a_6924_41600.n1 0.189974
R2332 a_6924_41600.n39 a_6924_41600.n24 0.1205
R2333 a_6924_41600.n39 a_6924_41600.n38 0.1205
R2334 a_6924_41600.n38 a_6924_41600.n37 0.1205
R2335 a_6924_41600.n27 a_6924_41600.n26 0.1205
R2336 a_6924_41600.n26 a_6924_41600.n25 0.1205
R2337 a_6924_41600.n43 a_6924_41600.n25 0.1205
R2338 a_6924_41600.n18 a_6924_41600.n3 0.1205
R2339 a_6924_41600.n18 a_6924_41600.n17 0.1205
R2340 a_6924_41600.n17 a_6924_41600.n16 0.1205
R2341 a_6924_41600.n6 a_6924_41600.n5 0.1205
R2342 a_6924_41600.n5 a_6924_41600.n4 0.1205
R2343 a_6924_41600.n22 a_6924_41600.n4 0.1205
R2344 a_6924_41600.n44 a_6924_41600.n24 0.0485
R2345 a_6924_41600.n44 a_6924_41600.n43 0.0485
R2346 a_6924_41600.n23 a_6924_41600.n3 0.0485
R2347 a_6924_41600.n23 a_6924_41600.n22 0.0485
R2348 a_4812_41600.n18 a_4812_41600.t15 113.632
R2349 a_4812_41600.n22 a_4812_41600.t8 113.632
R2350 a_4812_41600.n5 a_4812_41600.t23 113.632
R2351 a_4812_41600.n9 a_4812_41600.t16 113.632
R2352 a_4812_41600.n25 a_4812_41600.t11 109.174
R2353 a_4812_41600.n26 a_4812_41600.t12 109.174
R2354 a_4812_41600.n19 a_4812_41600.t14 109.174
R2355 a_4812_41600.n20 a_4812_41600.t13 109.174
R2356 a_4812_41600.n24 a_4812_41600.t10 109.174
R2357 a_4812_41600.n21 a_4812_41600.t9 109.174
R2358 a_4812_41600.n12 a_4812_41600.t19 109.174
R2359 a_4812_41600.n13 a_4812_41600.t20 109.174
R2360 a_4812_41600.n6 a_4812_41600.t22 109.174
R2361 a_4812_41600.n7 a_4812_41600.t21 109.174
R2362 a_4812_41600.n11 a_4812_41600.t18 109.174
R2363 a_4812_41600.n8 a_4812_41600.t17 109.174
R2364 a_4812_41600.n25 a_4812_41600.n16 18.4942
R2365 a_4812_41600.n27 a_4812_41600.n26 18.4942
R2366 a_4812_41600.n20 a_4812_41600.n17 18.4942
R2367 a_4812_41600.n24 a_4812_41600.n23 18.4942
R2368 a_4812_41600.n12 a_4812_41600.n3 18.4942
R2369 a_4812_41600.n14 a_4812_41600.n13 18.4942
R2370 a_4812_41600.n7 a_4812_41600.n4 18.4942
R2371 a_4812_41600.n11 a_4812_41600.n10 18.4942
R2372 a_4812_41600.n30 a_4812_41600.n29 17.3044
R2373 a_4812_41600.n25 a_4812_41600.n24 11.6805
R2374 a_4812_41600.n26 a_4812_41600.n25 11.6805
R2375 a_4812_41600.n20 a_4812_41600.n19 11.6805
R2376 a_4812_41600.n26 a_4812_41600.n20 11.6805
R2377 a_4812_41600.n24 a_4812_41600.n21 11.6805
R2378 a_4812_41600.n12 a_4812_41600.n11 11.6805
R2379 a_4812_41600.n13 a_4812_41600.n12 11.6805
R2380 a_4812_41600.n7 a_4812_41600.n6 11.6805
R2381 a_4812_41600.n13 a_4812_41600.n7 11.6805
R2382 a_4812_41600.n11 a_4812_41600.n8 11.6805
R2383 a_4812_41600.n29 a_4812_41600.n15 10.3505
R2384 a_4812_41600.n29 a_4812_41600.n28 9.57907
R2385 a_4812_41600.n23 a_4812_41600.n22 7.17687
R2386 a_4812_41600.n18 a_4812_41600.n17 7.17687
R2387 a_4812_41600.n10 a_4812_41600.n9 7.17687
R2388 a_4812_41600.n5 a_4812_41600.n4 7.17687
R2389 a_4812_41600.n30 a_4812_41600.n2 6.5392
R2390 a_4812_41600.t3 a_4812_41600.n33 5.7796
R2391 a_4812_41600.n1 a_4812_41600.t7 5.73764
R2392 a_4812_41600.n31 a_4812_41600.t0 5.59012
R2393 a_4812_41600.n2 a_4812_41600.t4 5.54817
R2394 a_4812_41600.n33 a_4812_41600.n32 5.38537
R2395 a_4812_41600.n1 a_4812_41600.n0 5.32067
R2396 a_4812_41600.n31 a_4812_41600.n30 4.61063
R2397 a_4812_41600.n19 a_4812_41600.n18 4.42851
R2398 a_4812_41600.n22 a_4812_41600.n21 4.42851
R2399 a_4812_41600.n6 a_4812_41600.n5 4.42851
R2400 a_4812_41600.n9 a_4812_41600.n8 4.42851
R2401 a_4812_41600.n0 a_4812_41600.t5 0.228
R2402 a_4812_41600.n0 a_4812_41600.t6 0.228
R2403 a_4812_41600.n32 a_4812_41600.t1 0.20525
R2404 a_4812_41600.n32 a_4812_41600.t2 0.20525
R2405 a_4812_41600.n33 a_4812_41600.n31 0.189974
R2406 a_4812_41600.n2 a_4812_41600.n1 0.189974
R2407 a_4812_41600.n23 a_4812_41600.n16 0.1205
R2408 a_4812_41600.n27 a_4812_41600.n17 0.1205
R2409 a_4812_41600.n10 a_4812_41600.n3 0.1205
R2410 a_4812_41600.n14 a_4812_41600.n4 0.1205
R2411 a_4812_41600.n28 a_4812_41600.n16 0.0485
R2412 a_4812_41600.n28 a_4812_41600.n27 0.0485
R2413 a_4812_41600.n15 a_4812_41600.n3 0.0485
R2414 a_4812_41600.n15 a_4812_41600.n14 0.0485
R2415 a_2700_41600.n18 a_2700_41600.t15 113.632
R2416 a_2700_41600.n22 a_2700_41600.t8 113.632
R2417 a_2700_41600.n5 a_2700_41600.t23 113.632
R2418 a_2700_41600.n9 a_2700_41600.t16 113.632
R2419 a_2700_41600.n25 a_2700_41600.t11 109.174
R2420 a_2700_41600.n26 a_2700_41600.t12 109.174
R2421 a_2700_41600.n19 a_2700_41600.t14 109.174
R2422 a_2700_41600.n20 a_2700_41600.t13 109.174
R2423 a_2700_41600.n24 a_2700_41600.t10 109.174
R2424 a_2700_41600.n21 a_2700_41600.t9 109.174
R2425 a_2700_41600.n12 a_2700_41600.t19 109.174
R2426 a_2700_41600.n13 a_2700_41600.t20 109.174
R2427 a_2700_41600.n6 a_2700_41600.t22 109.174
R2428 a_2700_41600.n7 a_2700_41600.t21 109.174
R2429 a_2700_41600.n11 a_2700_41600.t18 109.174
R2430 a_2700_41600.n8 a_2700_41600.t17 109.174
R2431 a_2700_41600.n25 a_2700_41600.n16 18.4942
R2432 a_2700_41600.n27 a_2700_41600.n26 18.4942
R2433 a_2700_41600.n20 a_2700_41600.n17 18.4942
R2434 a_2700_41600.n24 a_2700_41600.n23 18.4942
R2435 a_2700_41600.n12 a_2700_41600.n3 18.4942
R2436 a_2700_41600.n14 a_2700_41600.n13 18.4942
R2437 a_2700_41600.n7 a_2700_41600.n4 18.4942
R2438 a_2700_41600.n11 a_2700_41600.n10 18.4942
R2439 a_2700_41600.n30 a_2700_41600.n29 17.0158
R2440 a_2700_41600.n25 a_2700_41600.n24 11.6805
R2441 a_2700_41600.n26 a_2700_41600.n25 11.6805
R2442 a_2700_41600.n20 a_2700_41600.n19 11.6805
R2443 a_2700_41600.n26 a_2700_41600.n20 11.6805
R2444 a_2700_41600.n24 a_2700_41600.n21 11.6805
R2445 a_2700_41600.n12 a_2700_41600.n11 11.6805
R2446 a_2700_41600.n13 a_2700_41600.n12 11.6805
R2447 a_2700_41600.n7 a_2700_41600.n6 11.6805
R2448 a_2700_41600.n13 a_2700_41600.n7 11.6805
R2449 a_2700_41600.n11 a_2700_41600.n8 11.6805
R2450 a_2700_41600.n29 a_2700_41600.n15 10.688
R2451 a_2700_41600.n29 a_2700_41600.n28 9.24157
R2452 a_2700_41600.n23 a_2700_41600.n22 7.17687
R2453 a_2700_41600.n18 a_2700_41600.n17 7.17687
R2454 a_2700_41600.n10 a_2700_41600.n9 7.17687
R2455 a_2700_41600.n5 a_2700_41600.n4 7.17687
R2456 a_2700_41600.n30 a_2700_41600.n2 6.5392
R2457 a_2700_41600.t3 a_2700_41600.n33 5.7796
R2458 a_2700_41600.n1 a_2700_41600.t7 5.73764
R2459 a_2700_41600.n31 a_2700_41600.t0 5.59012
R2460 a_2700_41600.n2 a_2700_41600.t4 5.54817
R2461 a_2700_41600.n33 a_2700_41600.n32 5.38537
R2462 a_2700_41600.n1 a_2700_41600.n0 5.32067
R2463 a_2700_41600.n31 a_2700_41600.n30 4.61063
R2464 a_2700_41600.n19 a_2700_41600.n18 4.42851
R2465 a_2700_41600.n22 a_2700_41600.n21 4.42851
R2466 a_2700_41600.n6 a_2700_41600.n5 4.42851
R2467 a_2700_41600.n9 a_2700_41600.n8 4.42851
R2468 a_2700_41600.n0 a_2700_41600.t5 0.228
R2469 a_2700_41600.n0 a_2700_41600.t6 0.228
R2470 a_2700_41600.n32 a_2700_41600.t1 0.20525
R2471 a_2700_41600.n32 a_2700_41600.t2 0.20525
R2472 a_2700_41600.n33 a_2700_41600.n31 0.189974
R2473 a_2700_41600.n2 a_2700_41600.n1 0.189974
R2474 a_2700_41600.n23 a_2700_41600.n16 0.1205
R2475 a_2700_41600.n27 a_2700_41600.n17 0.1205
R2476 a_2700_41600.n10 a_2700_41600.n3 0.1205
R2477 a_2700_41600.n14 a_2700_41600.n4 0.1205
R2478 a_2700_41600.n28 a_2700_41600.n16 0.0485
R2479 a_2700_41600.n28 a_2700_41600.n27 0.0485
R2480 a_2700_41600.n15 a_2700_41600.n3 0.0485
R2481 a_2700_41600.n15 a_2700_41600.n14 0.0485
C0 VDD CLKP_HB 3.08923f
C1 O_CAPTURE_CLKB O_CAPTURE_CLK 0.13895f
C2 O_CAPTURE_CLK VDD 11.2501f
C3 O_CAPTURE_CLKB VDD 11.3084f
C4 CLKN_H CLKN_HB 0.13381f
C5 E_CAPTURE_CLKB E_CAPTURE_CLK 0.13895f
C6 CLKP_HB CLKP_H 0.13381f
C7 VDD O_SENSE 40.9203f
C8 E_CAPTURE_CLKB CLKP_HB 0.04486f
C9 VDD CLKP_H 2.93876f
C10 CLKN_H VDD 2.93876f
C11 O_CAPTURE_CLKB CLKN_HB 0.04486f
C12 E_SENSE VDD 40.9203f
C13 E_CAPTURE_CLK VDD 11.2501f
C14 E_CAPTURE_CLKB VDD 11.3084f
C15 VDD CLKN_HB 3.08923f
C16 E_SENSE VSS 45.84943f
C17 E_CAPTURE_CLK VSS 13.22105f
C18 E_CAPTURE_CLKB VSS 11.51597f
C19 CLKP_H VSS 8.92236f
C20 CLKP_HB VSS 10.42647f
C21 O_SENSE VSS 45.84943f
C22 O_CAPTURE_CLK VSS 13.22105f
C23 O_CAPTURE_CLKB VSS 11.51597f
C24 CLKN_H VSS 8.92236f
C25 CLKN_HB VSS 10.89566f
C26 VDD VSS 2.46155p
C27 a_2700_41600.t7 VSS 0.78846f
C28 a_2700_41600.t6 VSS 0.18273f
C29 a_2700_41600.t5 VSS 0.18273f
C30 a_2700_41600.n0 VSS 0.58157f
C31 a_2700_41600.n1 VSS 0.31967f
C32 a_2700_41600.t4 VSS 0.78324f
C33 a_2700_41600.n2 VSS 0.34526f
C34 a_2700_41600.n3 VSS 0.05376f
C35 a_2700_41600.n4 VSS 0.18572f
C36 a_2700_41600.n5 VSS 0.0918f
C37 a_2700_41600.n6 VSS 0.0984f
C38 a_2700_41600.n7 VSS 0.0984f
C39 a_2700_41600.n8 VSS 0.0984f
C40 a_2700_41600.n9 VSS 0.0918f
C41 a_2700_41600.n10 VSS 0.18572f
C42 a_2700_41600.n11 VSS 0.0984f
C43 a_2700_41600.n12 VSS 0.0984f
C44 a_2700_41600.n13 VSS 0.0984f
C45 a_2700_41600.n14 VSS 0.05376f
C46 a_2700_41600.n15 VSS 0.30181f
C47 a_2700_41600.n16 VSS 0.05376f
C48 a_2700_41600.n17 VSS 0.18572f
C49 a_2700_41600.n18 VSS 0.0918f
C50 a_2700_41600.n19 VSS 0.0984f
C51 a_2700_41600.n20 VSS 0.0984f
C52 a_2700_41600.n21 VSS 0.0984f
C53 a_2700_41600.n22 VSS 0.0918f
C54 a_2700_41600.n23 VSS 0.18572f
C55 a_2700_41600.n24 VSS 0.0984f
C56 a_2700_41600.n25 VSS 0.0984f
C57 a_2700_41600.n26 VSS 0.0984f
C58 a_2700_41600.n27 VSS 0.05376f
C59 a_2700_41600.n28 VSS 0.22605f
C60 a_2700_41600.n29 VSS 2.02655f
C61 a_2700_41600.n30 VSS 1.88452f
C62 a_2700_41600.t0 VSS 0.78185f
C63 a_2700_41600.n31 VSS 0.23411f
C64 a_2700_41600.t2 VSS 0.18273f
C65 a_2700_41600.t1 VSS 0.18273f
C66 a_2700_41600.n32 VSS 0.57729f
C67 a_2700_41600.n33 VSS 0.32535f
C68 a_2700_41600.t3 VSS 0.78707f
C69 a_4812_41600.t7 VSS 0.81128f
C70 a_4812_41600.t6 VSS 0.18016f
C71 a_4812_41600.t5 VSS 0.18016f
C72 a_4812_41600.n0 VSS 0.60614f
C73 a_4812_41600.n1 VSS 0.33317f
C74 a_4812_41600.t4 VSS 0.80584f
C75 a_4812_41600.n2 VSS 0.35985f
C76 a_4812_41600.n3 VSS 0.05603f
C77 a_4812_41600.n4 VSS 0.19357f
C78 a_4812_41600.n5 VSS 0.09568f
C79 a_4812_41600.n6 VSS 0.10256f
C80 a_4812_41600.n7 VSS 0.10256f
C81 a_4812_41600.n8 VSS 0.10256f
C82 a_4812_41600.n9 VSS 0.09568f
C83 a_4812_41600.n10 VSS 0.19357f
C84 a_4812_41600.n11 VSS 0.10256f
C85 a_4812_41600.n12 VSS 0.10256f
C86 a_4812_41600.n13 VSS 0.10256f
C87 a_4812_41600.n14 VSS 0.05603f
C88 a_4812_41600.n15 VSS 0.29102f
C89 a_4812_41600.n16 VSS 0.05603f
C90 a_4812_41600.n17 VSS 0.19357f
C91 a_4812_41600.n18 VSS 0.09568f
C92 a_4812_41600.n19 VSS 0.10256f
C93 a_4812_41600.n20 VSS 0.10256f
C94 a_4812_41600.n21 VSS 0.10256f
C95 a_4812_41600.n22 VSS 0.09568f
C96 a_4812_41600.n23 VSS 0.19357f
C97 a_4812_41600.n24 VSS 0.10256f
C98 a_4812_41600.n25 VSS 0.10256f
C99 a_4812_41600.n26 VSS 0.10256f
C100 a_4812_41600.n27 VSS 0.05603f
C101 a_4812_41600.n28 VSS 0.24849f
C102 a_4812_41600.n29 VSS 2.18227f
C103 a_4812_41600.n30 VSS 1.93796f
C104 a_4812_41600.t0 VSS 0.80438f
C105 a_4812_41600.n31 VSS 0.244f
C106 a_4812_41600.t2 VSS 0.18016f
C107 a_4812_41600.t1 VSS 0.18016f
C108 a_4812_41600.n32 VSS 0.60167f
C109 a_4812_41600.n33 VSS 0.33909f
C110 a_4812_41600.t3 VSS 0.80983f
C111 a_6924_41600.t7 VSS 0.76877f
C112 a_6924_41600.t6 VSS 0.17964f
C113 a_6924_41600.t5 VSS 0.17964f
C114 a_6924_41600.n0 VSS 0.56559f
C115 a_6924_41600.n1 VSS 0.31089f
C116 a_6924_41600.t4 VSS 0.76369f
C117 a_6924_41600.n2 VSS 0.33578f
C118 a_6924_41600.n3 VSS 0.05228f
C119 a_6924_41600.n4 VSS 0.06206f
C120 a_6924_41600.n5 VSS 0.06206f
C121 a_6924_41600.n6 VSS 0.18062f
C122 a_6924_41600.n7 VSS 0.08928f
C123 a_6924_41600.n8 VSS 0.0957f
C124 a_6924_41600.n9 VSS 0.0957f
C125 a_6924_41600.n10 VSS 0.0957f
C126 a_6924_41600.n11 VSS 0.0957f
C127 a_6924_41600.n12 VSS 0.0957f
C128 a_6924_41600.n13 VSS 0.08928f
C129 a_6924_41600.n14 VSS 0.0957f
C130 a_6924_41600.n15 VSS 0.0957f
C131 a_6924_41600.n16 VSS 0.18062f
C132 a_6924_41600.n17 VSS 0.06206f
C133 a_6924_41600.n18 VSS 0.06206f
C134 a_6924_41600.n19 VSS 0.0957f
C135 a_6924_41600.n20 VSS 0.0957f
C136 a_6924_41600.n21 VSS 0.0957f
C137 a_6924_41600.n22 VSS 0.05228f
C138 a_6924_41600.n23 VSS 0.35592f
C139 a_6924_41600.n24 VSS 0.05228f
C140 a_6924_41600.n25 VSS 0.06206f
C141 a_6924_41600.n26 VSS 0.06206f
C142 a_6924_41600.n27 VSS 0.18062f
C143 a_6924_41600.n28 VSS 0.08928f
C144 a_6924_41600.n29 VSS 0.0957f
C145 a_6924_41600.n30 VSS 0.0957f
C146 a_6924_41600.n31 VSS 0.0957f
C147 a_6924_41600.n32 VSS 0.0957f
C148 a_6924_41600.n33 VSS 0.0957f
C149 a_6924_41600.n34 VSS 0.08928f
C150 a_6924_41600.n35 VSS 0.0957f
C151 a_6924_41600.n36 VSS 0.0957f
C152 a_6924_41600.n37 VSS 0.18062f
C153 a_6924_41600.n38 VSS 0.06206f
C154 a_6924_41600.n39 VSS 0.06206f
C155 a_6924_41600.n40 VSS 0.0957f
C156 a_6924_41600.n41 VSS 0.0957f
C157 a_6924_41600.n42 VSS 0.0957f
C158 a_6924_41600.n43 VSS 0.05228f
C159 a_6924_41600.n44 VSS 0.35012f
C160 a_6924_41600.n45 VSS 2.30487f
C161 a_6924_41600.n46 VSS 1.82211f
C162 a_6924_41600.t0 VSS 0.76233f
C163 a_6924_41600.n47 VSS 0.22768f
C164 a_6924_41600.t2 VSS 0.17964f
C165 a_6924_41600.t1 VSS 0.17964f
C166 a_6924_41600.n48 VSS 0.56142f
C167 a_6924_41600.n49 VSS 0.31641f
C168 a_6924_41600.t3 VSS 0.76742f
C169 a_14540_41600.t8 VSS 0.20017f
C170 a_14540_41600.t15 VSS 0.77907f
C171 a_14540_41600.t16 VSS 0.20017f
C172 a_14540_41600.t17 VSS 0.20017f
C173 a_14540_41600.n0 VSS 0.55534f
C174 a_14540_41600.n1 VSS 0.30525f
C175 a_14540_41600.t18 VSS 0.20017f
C176 a_14540_41600.t19 VSS 0.20017f
C177 a_14540_41600.n2 VSS 0.55534f
C178 a_14540_41600.n3 VSS 0.15935f
C179 a_14540_41600.t20 VSS 0.20017f
C180 a_14540_41600.t22 VSS 0.20017f
C181 a_14540_41600.n4 VSS 0.55534f
C182 a_14540_41600.n5 VSS 0.15935f
C183 a_14540_41600.t23 VSS 0.20017f
C184 a_14540_41600.t7 VSS 0.20017f
C185 a_14540_41600.n6 VSS 0.55534f
C186 a_14540_41600.n7 VSS 0.15935f
C187 a_14540_41600.n8 VSS 0.05134f
C188 a_14540_41600.n9 VSS 0.06093f
C189 a_14540_41600.n10 VSS 0.06093f
C190 a_14540_41600.n11 VSS 0.06093f
C191 a_14540_41600.n12 VSS 0.06093f
C192 a_14540_41600.n13 VSS 0.06093f
C193 a_14540_41600.n14 VSS 0.06093f
C194 a_14540_41600.n15 VSS 0.06093f
C195 a_14540_41600.n16 VSS 0.06093f
C196 a_14540_41600.n17 VSS 0.06093f
C197 a_14540_41600.n18 VSS 0.06093f
C198 a_14540_41600.n19 VSS 0.06093f
C199 a_14540_41600.n20 VSS 0.06093f
C200 a_14540_41600.n21 VSS 0.17734f
C201 a_14540_41600.n22 VSS 0.08766f
C202 a_14540_41600.n23 VSS 0.09396f
C203 a_14540_41600.n24 VSS 0.09396f
C204 a_14540_41600.n25 VSS 0.09396f
C205 a_14540_41600.n26 VSS 0.09396f
C206 a_14540_41600.n27 VSS 0.09396f
C207 a_14540_41600.n28 VSS 0.09396f
C208 a_14540_41600.n29 VSS 0.09396f
C209 a_14540_41600.n30 VSS 0.09396f
C210 a_14540_41600.n31 VSS 0.09396f
C211 a_14540_41600.n32 VSS 0.09396f
C212 a_14540_41600.n33 VSS 0.09396f
C213 a_14540_41600.n34 VSS 0.09396f
C214 a_14540_41600.n35 VSS 0.09396f
C215 a_14540_41600.n36 VSS 0.09396f
C216 a_14540_41600.n37 VSS 0.09396f
C217 a_14540_41600.n38 VSS 0.06093f
C218 a_14540_41600.n39 VSS 0.09396f
C219 a_14540_41600.n40 VSS 0.06093f
C220 a_14540_41600.n41 VSS 0.09396f
C221 a_14540_41600.n42 VSS 0.06093f
C222 a_14540_41600.n43 VSS 0.09396f
C223 a_14540_41600.n44 VSS 0.08766f
C224 a_14540_41600.n45 VSS 0.17734f
C225 a_14540_41600.n46 VSS 0.09396f
C226 a_14540_41600.n47 VSS 0.09396f
C227 a_14540_41600.n48 VSS 0.09396f
C228 a_14540_41600.n49 VSS 0.06093f
C229 a_14540_41600.n50 VSS 0.06093f
C230 a_14540_41600.n51 VSS 0.06093f
C231 a_14540_41600.n52 VSS 0.09396f
C232 a_14540_41600.n53 VSS 0.09396f
C233 a_14540_41600.n54 VSS 0.09396f
C234 a_14540_41600.n55 VSS 0.06093f
C235 a_14540_41600.n56 VSS 0.06093f
C236 a_14540_41600.n57 VSS 0.06093f
C237 a_14540_41600.n58 VSS 0.09396f
C238 a_14540_41600.n59 VSS 0.09396f
C239 a_14540_41600.n60 VSS 0.09396f
C240 a_14540_41600.n61 VSS 0.06093f
C241 a_14540_41600.n62 VSS 0.06093f
C242 a_14540_41600.n63 VSS 0.06093f
C243 a_14540_41600.n64 VSS 0.09396f
C244 a_14540_41600.n65 VSS 0.09396f
C245 a_14540_41600.n66 VSS 0.09396f
C246 a_14540_41600.n67 VSS 0.05134f
C247 a_14540_41600.n68 VSS 0.93034f
C248 a_14540_41600.n69 VSS 0.05134f
C249 a_14540_41600.n70 VSS 0.06093f
C250 a_14540_41600.n71 VSS 0.06093f
C251 a_14540_41600.n72 VSS 0.06093f
C252 a_14540_41600.n73 VSS 0.06093f
C253 a_14540_41600.n74 VSS 0.06093f
C254 a_14540_41600.n75 VSS 0.06093f
C255 a_14540_41600.n76 VSS 0.06093f
C256 a_14540_41600.n77 VSS 0.06093f
C257 a_14540_41600.n78 VSS 0.06093f
C258 a_14540_41600.n79 VSS 0.06093f
C259 a_14540_41600.n80 VSS 0.06093f
C260 a_14540_41600.n81 VSS 0.06093f
C261 a_14540_41600.n82 VSS 0.17734f
C262 a_14540_41600.n83 VSS 0.08766f
C263 a_14540_41600.n84 VSS 0.09396f
C264 a_14540_41600.n85 VSS 0.09396f
C265 a_14540_41600.n86 VSS 0.09396f
C266 a_14540_41600.n87 VSS 0.09396f
C267 a_14540_41600.n88 VSS 0.09396f
C268 a_14540_41600.n89 VSS 0.09396f
C269 a_14540_41600.n90 VSS 0.09396f
C270 a_14540_41600.n91 VSS 0.09396f
C271 a_14540_41600.n92 VSS 0.09396f
C272 a_14540_41600.n93 VSS 0.09396f
C273 a_14540_41600.n94 VSS 0.09396f
C274 a_14540_41600.n95 VSS 0.09396f
C275 a_14540_41600.n96 VSS 0.09396f
C276 a_14540_41600.n97 VSS 0.09396f
C277 a_14540_41600.n98 VSS 0.09396f
C278 a_14540_41600.n99 VSS 0.06093f
C279 a_14540_41600.n100 VSS 0.09396f
C280 a_14540_41600.n101 VSS 0.06093f
C281 a_14540_41600.n102 VSS 0.09396f
C282 a_14540_41600.n103 VSS 0.06093f
C283 a_14540_41600.n104 VSS 0.09396f
C284 a_14540_41600.n105 VSS 0.08766f
C285 a_14540_41600.n106 VSS 0.17734f
C286 a_14540_41600.n107 VSS 0.09396f
C287 a_14540_41600.n108 VSS 0.09396f
C288 a_14540_41600.n109 VSS 0.09396f
C289 a_14540_41600.n110 VSS 0.06093f
C290 a_14540_41600.n111 VSS 0.06093f
C291 a_14540_41600.n112 VSS 0.06093f
C292 a_14540_41600.n113 VSS 0.09396f
C293 a_14540_41600.n114 VSS 0.09396f
C294 a_14540_41600.n115 VSS 0.09396f
C295 a_14540_41600.n116 VSS 0.06093f
C296 a_14540_41600.n117 VSS 0.06093f
C297 a_14540_41600.n118 VSS 0.06093f
C298 a_14540_41600.n119 VSS 0.09396f
C299 a_14540_41600.n120 VSS 0.09396f
C300 a_14540_41600.n121 VSS 0.09396f
C301 a_14540_41600.n122 VSS 0.06093f
C302 a_14540_41600.n123 VSS 0.06093f
C303 a_14540_41600.n124 VSS 0.06093f
C304 a_14540_41600.n125 VSS 0.09396f
C305 a_14540_41600.n126 VSS 0.09396f
C306 a_14540_41600.n127 VSS 0.09396f
C307 a_14540_41600.n128 VSS 0.05134f
C308 a_14540_41600.n129 VSS 0.7849f
C309 a_14540_41600.n130 VSS 2.81703f
C310 a_14540_41600.t21 VSS 0.77774f
C311 a_14540_41600.t4 VSS 0.20017f
C312 a_14540_41600.t5 VSS 0.20017f
C313 a_14540_41600.n131 VSS 0.55124f
C314 a_14540_41600.n132 VSS 0.31067f
C315 a_14540_41600.t6 VSS 0.20017f
C316 a_14540_41600.t13 VSS 0.20017f
C317 a_14540_41600.n133 VSS 0.55124f
C318 a_14540_41600.n134 VSS 0.16344f
C319 a_14540_41600.t14 VSS 0.20017f
C320 a_14540_41600.t11 VSS 0.20017f
C321 a_14540_41600.n135 VSS 0.55124f
C322 a_14540_41600.n136 VSS 0.16344f
C323 a_14540_41600.t12 VSS 0.20017f
C324 a_14540_41600.t9 VSS 0.20017f
C325 a_14540_41600.n137 VSS 0.55124f
C326 a_14540_41600.n138 VSS 0.16344f
C327 a_14540_41600.t10 VSS 0.20017f
C328 a_14540_41600.t2 VSS 0.20017f
C329 a_14540_41600.n139 VSS 0.55124f
C330 a_14540_41600.n140 VSS 0.16344f
C331 a_14540_41600.t3 VSS 0.77275f
C332 a_14540_41600.n141 VSS 0.22355f
C333 a_14540_41600.n142 VSS 1.68176f
C334 a_14540_41600.t1 VSS 0.77408f
C335 a_14540_41600.n143 VSS 0.32969f
C336 a_14540_41600.n144 VSS 0.15935f
C337 a_14540_41600.n145 VSS 0.55534f
C338 a_14540_41600.t0 VSS 0.20017f
C339 a_2700_6400.t7 VSS 0.78987f
C340 a_2700_6400.t6 VSS 0.18411f
C341 a_2700_6400.t5 VSS 0.18411f
C342 a_2700_6400.n0 VSS 0.58157f
C343 a_2700_6400.n1 VSS 0.31967f
C344 a_2700_6400.t4 VSS 0.78465f
C345 a_2700_6400.n2 VSS 0.34526f
C346 a_2700_6400.n3 VSS 0.05376f
C347 a_2700_6400.n4 VSS 0.18572f
C348 a_2700_6400.n5 VSS 0.0918f
C349 a_2700_6400.n6 VSS 0.0984f
C350 a_2700_6400.n7 VSS 0.0984f
C351 a_2700_6400.n8 VSS 0.0984f
C352 a_2700_6400.n9 VSS 0.0918f
C353 a_2700_6400.n10 VSS 0.18572f
C354 a_2700_6400.n11 VSS 0.0984f
C355 a_2700_6400.n12 VSS 0.0984f
C356 a_2700_6400.n13 VSS 0.0984f
C357 a_2700_6400.n14 VSS 0.05376f
C358 a_2700_6400.n15 VSS 0.30181f
C359 a_2700_6400.n16 VSS 0.05376f
C360 a_2700_6400.n17 VSS 0.18572f
C361 a_2700_6400.n18 VSS 0.0918f
C362 a_2700_6400.n19 VSS 0.0984f
C363 a_2700_6400.n20 VSS 0.0984f
C364 a_2700_6400.n21 VSS 0.0984f
C365 a_2700_6400.n22 VSS 0.0918f
C366 a_2700_6400.n23 VSS 0.18572f
C367 a_2700_6400.n24 VSS 0.0984f
C368 a_2700_6400.n25 VSS 0.0984f
C369 a_2700_6400.n26 VSS 0.0984f
C370 a_2700_6400.n27 VSS 0.05376f
C371 a_2700_6400.n28 VSS 0.22605f
C372 a_2700_6400.n29 VSS 2.02655f
C373 a_2700_6400.n30 VSS 1.88452f
C374 a_2700_6400.t0 VSS 0.78326f
C375 a_2700_6400.n31 VSS 0.23411f
C376 a_2700_6400.t2 VSS 0.18411f
C377 a_2700_6400.t1 VSS 0.18411f
C378 a_2700_6400.n32 VSS 0.57729f
C379 a_2700_6400.n33 VSS 0.32535f
C380 a_2700_6400.t3 VSS 0.78848f
C381 a_4812_6400.t7 VSS 0.81128f
C382 a_4812_6400.t6 VSS 0.18016f
C383 a_4812_6400.t5 VSS 0.18016f
C384 a_4812_6400.n0 VSS 0.60614f
C385 a_4812_6400.n1 VSS 0.33317f
C386 a_4812_6400.t4 VSS 0.80584f
C387 a_4812_6400.n2 VSS 0.35985f
C388 a_4812_6400.n3 VSS 0.05603f
C389 a_4812_6400.n4 VSS 0.19357f
C390 a_4812_6400.n5 VSS 0.09568f
C391 a_4812_6400.n6 VSS 0.10256f
C392 a_4812_6400.n7 VSS 0.10256f
C393 a_4812_6400.n8 VSS 0.10256f
C394 a_4812_6400.n9 VSS 0.09568f
C395 a_4812_6400.n10 VSS 0.19357f
C396 a_4812_6400.n11 VSS 0.10256f
C397 a_4812_6400.n12 VSS 0.10256f
C398 a_4812_6400.n13 VSS 0.10256f
C399 a_4812_6400.n14 VSS 0.05603f
C400 a_4812_6400.n15 VSS 0.29102f
C401 a_4812_6400.n16 VSS 0.05603f
C402 a_4812_6400.n17 VSS 0.19357f
C403 a_4812_6400.n18 VSS 0.09568f
C404 a_4812_6400.n19 VSS 0.10256f
C405 a_4812_6400.n20 VSS 0.10256f
C406 a_4812_6400.n21 VSS 0.10256f
C407 a_4812_6400.n22 VSS 0.09568f
C408 a_4812_6400.n23 VSS 0.19357f
C409 a_4812_6400.n24 VSS 0.10256f
C410 a_4812_6400.n25 VSS 0.10256f
C411 a_4812_6400.n26 VSS 0.10256f
C412 a_4812_6400.n27 VSS 0.05603f
C413 a_4812_6400.n28 VSS 0.24849f
C414 a_4812_6400.n29 VSS 2.18227f
C415 a_4812_6400.n30 VSS 1.93796f
C416 a_4812_6400.t0 VSS 0.80438f
C417 a_4812_6400.n31 VSS 0.244f
C418 a_4812_6400.t2 VSS 0.18016f
C419 a_4812_6400.t1 VSS 0.18016f
C420 a_4812_6400.n32 VSS 0.60167f
C421 a_4812_6400.n33 VSS 0.33909f
C422 a_4812_6400.t3 VSS 0.80983f
C423 a_6924_6400.t7 VSS 0.77017f
C424 a_6924_6400.t6 VSS 0.18102f
C425 a_6924_6400.t5 VSS 0.18102f
C426 a_6924_6400.n0 VSS 0.56559f
C427 a_6924_6400.n1 VSS 0.31089f
C428 a_6924_6400.t4 VSS 0.7651f
C429 a_6924_6400.n2 VSS 0.33578f
C430 a_6924_6400.n3 VSS 0.05228f
C431 a_6924_6400.n4 VSS 0.06206f
C432 a_6924_6400.n5 VSS 0.06206f
C433 a_6924_6400.n6 VSS 0.18062f
C434 a_6924_6400.n7 VSS 0.08928f
C435 a_6924_6400.n8 VSS 0.0957f
C436 a_6924_6400.n9 VSS 0.0957f
C437 a_6924_6400.n10 VSS 0.0957f
C438 a_6924_6400.n11 VSS 0.0957f
C439 a_6924_6400.n12 VSS 0.0957f
C440 a_6924_6400.n13 VSS 0.08928f
C441 a_6924_6400.n14 VSS 0.0957f
C442 a_6924_6400.n15 VSS 0.0957f
C443 a_6924_6400.n16 VSS 0.18062f
C444 a_6924_6400.n17 VSS 0.06206f
C445 a_6924_6400.n18 VSS 0.06206f
C446 a_6924_6400.n19 VSS 0.0957f
C447 a_6924_6400.n20 VSS 0.0957f
C448 a_6924_6400.n21 VSS 0.0957f
C449 a_6924_6400.n22 VSS 0.05228f
C450 a_6924_6400.n23 VSS 0.35592f
C451 a_6924_6400.n24 VSS 0.05228f
C452 a_6924_6400.n25 VSS 0.06206f
C453 a_6924_6400.n26 VSS 0.06206f
C454 a_6924_6400.n27 VSS 0.18062f
C455 a_6924_6400.n28 VSS 0.08928f
C456 a_6924_6400.n29 VSS 0.0957f
C457 a_6924_6400.n30 VSS 0.0957f
C458 a_6924_6400.n31 VSS 0.0957f
C459 a_6924_6400.n32 VSS 0.0957f
C460 a_6924_6400.n33 VSS 0.0957f
C461 a_6924_6400.n34 VSS 0.08928f
C462 a_6924_6400.n35 VSS 0.0957f
C463 a_6924_6400.n36 VSS 0.0957f
C464 a_6924_6400.n37 VSS 0.18062f
C465 a_6924_6400.n38 VSS 0.06206f
C466 a_6924_6400.n39 VSS 0.06206f
C467 a_6924_6400.n40 VSS 0.0957f
C468 a_6924_6400.n41 VSS 0.0957f
C469 a_6924_6400.n42 VSS 0.0957f
C470 a_6924_6400.n43 VSS 0.05228f
C471 a_6924_6400.n44 VSS 0.35012f
C472 a_6924_6400.n45 VSS 2.30487f
C473 a_6924_6400.n46 VSS 1.82211f
C474 a_6924_6400.t0 VSS 0.76374f
C475 a_6924_6400.n47 VSS 0.22768f
C476 a_6924_6400.t2 VSS 0.18102f
C477 a_6924_6400.t1 VSS 0.18102f
C478 a_6924_6400.n48 VSS 0.56142f
C479 a_6924_6400.n49 VSS 0.31641f
C480 a_6924_6400.t3 VSS 0.76882f
C481 a_14540_6400.t12 VSS 0.20017f
C482 a_14540_6400.t9 VSS 0.77907f
C483 a_14540_6400.t10 VSS 0.20017f
C484 a_14540_6400.t11 VSS 0.20017f
C485 a_14540_6400.n0 VSS 0.55534f
C486 a_14540_6400.n1 VSS 0.30525f
C487 a_14540_6400.n2 VSS 0.05134f
C488 a_14540_6400.n3 VSS 0.06093f
C489 a_14540_6400.n4 VSS 0.06093f
C490 a_14540_6400.n5 VSS 0.06093f
C491 a_14540_6400.n6 VSS 0.06093f
C492 a_14540_6400.n7 VSS 0.06093f
C493 a_14540_6400.n8 VSS 0.06093f
C494 a_14540_6400.n9 VSS 0.06093f
C495 a_14540_6400.n10 VSS 0.06093f
C496 a_14540_6400.n11 VSS 0.06093f
C497 a_14540_6400.n12 VSS 0.06093f
C498 a_14540_6400.n13 VSS 0.06093f
C499 a_14540_6400.n14 VSS 0.06093f
C500 a_14540_6400.n15 VSS 0.17734f
C501 a_14540_6400.n16 VSS 0.08766f
C502 a_14540_6400.n17 VSS 0.09396f
C503 a_14540_6400.n18 VSS 0.09396f
C504 a_14540_6400.n19 VSS 0.09396f
C505 a_14540_6400.n20 VSS 0.09396f
C506 a_14540_6400.n21 VSS 0.09396f
C507 a_14540_6400.n22 VSS 0.09396f
C508 a_14540_6400.n23 VSS 0.09396f
C509 a_14540_6400.n24 VSS 0.09396f
C510 a_14540_6400.n25 VSS 0.09396f
C511 a_14540_6400.n26 VSS 0.09396f
C512 a_14540_6400.n27 VSS 0.09396f
C513 a_14540_6400.n28 VSS 0.09396f
C514 a_14540_6400.n29 VSS 0.09396f
C515 a_14540_6400.n30 VSS 0.09396f
C516 a_14540_6400.n31 VSS 0.09396f
C517 a_14540_6400.n32 VSS 0.06093f
C518 a_14540_6400.n33 VSS 0.09396f
C519 a_14540_6400.n34 VSS 0.06093f
C520 a_14540_6400.n35 VSS 0.09396f
C521 a_14540_6400.n36 VSS 0.06093f
C522 a_14540_6400.n37 VSS 0.09396f
C523 a_14540_6400.n38 VSS 0.08766f
C524 a_14540_6400.n39 VSS 0.17734f
C525 a_14540_6400.n40 VSS 0.09396f
C526 a_14540_6400.n41 VSS 0.09396f
C527 a_14540_6400.n42 VSS 0.09396f
C528 a_14540_6400.n43 VSS 0.06093f
C529 a_14540_6400.n44 VSS 0.06093f
C530 a_14540_6400.n45 VSS 0.06093f
C531 a_14540_6400.n46 VSS 0.09396f
C532 a_14540_6400.n47 VSS 0.09396f
C533 a_14540_6400.n48 VSS 0.09396f
C534 a_14540_6400.n49 VSS 0.06093f
C535 a_14540_6400.n50 VSS 0.06093f
C536 a_14540_6400.n51 VSS 0.06093f
C537 a_14540_6400.n52 VSS 0.09396f
C538 a_14540_6400.n53 VSS 0.09396f
C539 a_14540_6400.n54 VSS 0.09396f
C540 a_14540_6400.n55 VSS 0.06093f
C541 a_14540_6400.n56 VSS 0.06093f
C542 a_14540_6400.n57 VSS 0.06093f
C543 a_14540_6400.n58 VSS 0.09396f
C544 a_14540_6400.n59 VSS 0.09396f
C545 a_14540_6400.n60 VSS 0.09396f
C546 a_14540_6400.n61 VSS 0.05134f
C547 a_14540_6400.n62 VSS 0.93034f
C548 a_14540_6400.n63 VSS 0.05134f
C549 a_14540_6400.n64 VSS 0.06093f
C550 a_14540_6400.n65 VSS 0.06093f
C551 a_14540_6400.n66 VSS 0.06093f
C552 a_14540_6400.n67 VSS 0.06093f
C553 a_14540_6400.n68 VSS 0.06093f
C554 a_14540_6400.n69 VSS 0.06093f
C555 a_14540_6400.n70 VSS 0.06093f
C556 a_14540_6400.n71 VSS 0.06093f
C557 a_14540_6400.n72 VSS 0.06093f
C558 a_14540_6400.n73 VSS 0.06093f
C559 a_14540_6400.n74 VSS 0.06093f
C560 a_14540_6400.n75 VSS 0.06093f
C561 a_14540_6400.n76 VSS 0.17734f
C562 a_14540_6400.n77 VSS 0.08766f
C563 a_14540_6400.n78 VSS 0.09396f
C564 a_14540_6400.n79 VSS 0.09396f
C565 a_14540_6400.n80 VSS 0.09396f
C566 a_14540_6400.n81 VSS 0.09396f
C567 a_14540_6400.n82 VSS 0.09396f
C568 a_14540_6400.n83 VSS 0.09396f
C569 a_14540_6400.n84 VSS 0.09396f
C570 a_14540_6400.n85 VSS 0.09396f
C571 a_14540_6400.n86 VSS 0.09396f
C572 a_14540_6400.n87 VSS 0.09396f
C573 a_14540_6400.n88 VSS 0.09396f
C574 a_14540_6400.n89 VSS 0.09396f
C575 a_14540_6400.n90 VSS 0.09396f
C576 a_14540_6400.n91 VSS 0.09396f
C577 a_14540_6400.n92 VSS 0.09396f
C578 a_14540_6400.n93 VSS 0.06093f
C579 a_14540_6400.n94 VSS 0.09396f
C580 a_14540_6400.n95 VSS 0.06093f
C581 a_14540_6400.n96 VSS 0.09396f
C582 a_14540_6400.n97 VSS 0.06093f
C583 a_14540_6400.n98 VSS 0.09396f
C584 a_14540_6400.n99 VSS 0.08766f
C585 a_14540_6400.n100 VSS 0.17734f
C586 a_14540_6400.n101 VSS 0.09396f
C587 a_14540_6400.n102 VSS 0.09396f
C588 a_14540_6400.n103 VSS 0.09396f
C589 a_14540_6400.n104 VSS 0.06093f
C590 a_14540_6400.n105 VSS 0.06093f
C591 a_14540_6400.n106 VSS 0.06093f
C592 a_14540_6400.n107 VSS 0.09396f
C593 a_14540_6400.n108 VSS 0.09396f
C594 a_14540_6400.n109 VSS 0.09396f
C595 a_14540_6400.n110 VSS 0.06093f
C596 a_14540_6400.n111 VSS 0.06093f
C597 a_14540_6400.n112 VSS 0.06093f
C598 a_14540_6400.n113 VSS 0.09396f
C599 a_14540_6400.n114 VSS 0.09396f
C600 a_14540_6400.n115 VSS 0.09396f
C601 a_14540_6400.n116 VSS 0.06093f
C602 a_14540_6400.n117 VSS 0.06093f
C603 a_14540_6400.n118 VSS 0.06093f
C604 a_14540_6400.n119 VSS 0.09396f
C605 a_14540_6400.n120 VSS 0.09396f
C606 a_14540_6400.n121 VSS 0.09396f
C607 a_14540_6400.n122 VSS 0.05134f
C608 a_14540_6400.n123 VSS 0.7849f
C609 a_14540_6400.n124 VSS 2.81703f
C610 a_14540_6400.t2 VSS 0.77774f
C611 a_14540_6400.t23 VSS 0.20017f
C612 a_14540_6400.t19 VSS 0.20017f
C613 a_14540_6400.n125 VSS 0.55124f
C614 a_14540_6400.n126 VSS 0.31067f
C615 a_14540_6400.t20 VSS 0.20017f
C616 a_14540_6400.t15 VSS 0.20017f
C617 a_14540_6400.n127 VSS 0.55124f
C618 a_14540_6400.n128 VSS 0.16344f
C619 a_14540_6400.t16 VSS 0.20017f
C620 a_14540_6400.t17 VSS 0.20017f
C621 a_14540_6400.n129 VSS 0.55124f
C622 a_14540_6400.n130 VSS 0.16344f
C623 a_14540_6400.t18 VSS 0.20017f
C624 a_14540_6400.t13 VSS 0.20017f
C625 a_14540_6400.n131 VSS 0.55124f
C626 a_14540_6400.n132 VSS 0.16344f
C627 a_14540_6400.t14 VSS 0.20017f
C628 a_14540_6400.t5 VSS 0.20017f
C629 a_14540_6400.n133 VSS 0.55124f
C630 a_14540_6400.n134 VSS 0.16344f
C631 a_14540_6400.t6 VSS 0.77275f
C632 a_14540_6400.n135 VSS 0.22355f
C633 a_14540_6400.n136 VSS 1.68176f
C634 a_14540_6400.t8 VSS 0.77408f
C635 a_14540_6400.n137 VSS 0.32969f
C636 a_14540_6400.t4 VSS 0.20017f
C637 a_14540_6400.t7 VSS 0.20017f
C638 a_14540_6400.n138 VSS 0.55534f
C639 a_14540_6400.n139 VSS 0.15935f
C640 a_14540_6400.t22 VSS 0.20017f
C641 a_14540_6400.t3 VSS 0.20017f
C642 a_14540_6400.n140 VSS 0.55534f
C643 a_14540_6400.n141 VSS 0.15935f
C644 a_14540_6400.t1 VSS 0.20017f
C645 a_14540_6400.t21 VSS 0.20017f
C646 a_14540_6400.n142 VSS 0.55534f
C647 a_14540_6400.n143 VSS 0.15935f
C648 a_14540_6400.n144 VSS 0.15935f
C649 a_14540_6400.n145 VSS 0.55534f
C650 a_14540_6400.t0 VSS 0.20017f
C651 VSS.t99 VSS 0.0912f
C652 VSS.t49 VSS 0.09295f
C653 VSS.t211 VSS 0.0912f
C654 VSS.t97 VSS 0.0912f
C655 VSS.t285 VSS 0.0912f
C656 VSS.t209 VSS 0.0912f
C657 VSS.t53 VSS 0.0912f
C658 VSS.t283 VSS 0.0912f
C659 VSS.t275 VSS 0.0912f
C660 VSS.t51 VSS 0.0912f
C661 VSS.t19 VSS 0.0912f
C662 VSS.t273 VSS 0.0912f
C663 VSS.t121 VSS 0.0912f
C664 VSS.t17 VSS 0.0912f
C665 VSS.t133 VSS 0.0912f
C666 VSS.t119 VSS 0.0912f
C667 VSS.t43 VSS 0.0912f
C668 VSS.t131 VSS 0.0912f
C669 VSS.t125 VSS 0.0912f
C670 VSS.t41 VSS 0.0912f
C671 VSS.t83 VSS 0.0912f
C672 VSS.t123 VSS 0.0912f
C673 VSS.t15 VSS 0.0912f
C674 VSS.t81 VSS 0.0912f
C675 VSS.t47 VSS 0.0912f
C676 VSS.t13 VSS 0.0912f
C677 VSS.t129 VSS 0.0912f
C678 VSS.t45 VSS 0.0912f
C679 VSS.t187 VSS 0.0912f
C680 VSS.t127 VSS 0.0912f
C681 VSS.t279 VSS 0.09295f
C682 VSS.t185 VSS 0.0912f
C683 VSS.t25 VSS 0.09288f
C684 VSS.t27 VSS 0.09466f
C685 VSS.t145 VSS 0.09288f
C686 VSS.t147 VSS 0.09288f
C687 VSS.t161 VSS 0.09288f
C688 VSS.t163 VSS 0.09288f
C689 VSS.t149 VSS 0.09288f
C690 VSS.t151 VSS 0.09288f
C691 VSS.t173 VSS 0.09288f
C692 VSS.t175 VSS 0.09288f
C693 VSS.t1 VSS 0.09466f
C694 VSS.t219 VSS 0.09288f
C695 VSS.t195 VSS 0.09954f
C696 VSS.t197 VSS 0.10145f
C697 VSS.t143 VSS 0.09954f
C698 VSS.t193 VSS 0.09954f
C699 VSS.t215 VSS 0.09954f
C700 VSS.t141 VSS 0.09954f
C701 VSS.t199 VSS 0.10145f
C702 VSS.t213 VSS 0.09954f
C703 VSS.t21 VSS 0.09551f
C704 VSS.t189 VSS 0.09734f
C705 VSS.t101 VSS 0.09551f
C706 VSS.t191 VSS 0.09551f
C707 VSS.t221 VSS 0.09551f
C708 VSS.t287 VSS 0.09551f
C709 VSS.t223 VSS 0.09734f
C710 VSS.t217 VSS 0.09551f
C711 VSS.t235 VSS 0.07175f
C712 VSS.t225 VSS 0.07313f
C713 VSS.t239 VSS 0.07313f
C714 VSS.t231 VSS 0.07175f
C715 VSS.t267 VSS 0.06306f
C716 VSS.t265 VSS 0.06427f
C717 VSS.t271 VSS 0.06427f
C718 VSS.t269 VSS 0.06306f
C719 VSS.t233 VSS 0.07175f
C720 VSS.t227 VSS 0.07313f
C721 VSS.t229 VSS 0.07313f
C722 VSS.t237 VSS 0.07175f
C723 VSS.t261 VSS 0.07037f
C724 VSS.t251 VSS 0.07172f
C725 VSS.t249 VSS 0.07172f
C726 VSS.t255 VSS 0.07037f
C727 VSS.t243 VSS 0.06306f
C728 VSS.t241 VSS 0.06427f
C729 VSS.t247 VSS 0.06427f
C730 VSS.t245 VSS 0.06306f
C731 VSS.t259 VSS 0.07037f
C732 VSS.t257 VSS 0.07172f
C733 VSS.t253 VSS 0.07172f
C734 VSS.t263 VSS 0.07037f
C735 VSS.t85 VSS 0.09551f
C736 VSS.t87 VSS 0.09734f
C737 VSS.t67 VSS 0.09551f
C738 VSS.t139 VSS 0.09551f
C739 VSS.t65 VSS 0.09551f
C740 VSS.t23 VSS 0.09551f
C741 VSS.t103 VSS 0.09734f
C742 VSS.t277 VSS 0.09551f
C743 VSS.t93 VSS 0.09954f
C744 VSS.t95 VSS 0.10145f
C745 VSS.t61 VSS 0.09954f
C746 VSS.t63 VSS 0.09954f
C747 VSS.t169 VSS 0.09954f
C748 VSS.t171 VSS 0.09954f
C749 VSS.t201 VSS 0.10145f
C750 VSS.t203 VSS 0.09954f
C751 VSS.t55 VSS 0.09288f
C752 VSS.t57 VSS 0.09466f
C753 VSS.t135 VSS 0.09288f
C754 VSS.t137 VSS 0.09288f
C755 VSS.t153 VSS 0.09288f
C756 VSS.t155 VSS 0.09288f
C757 VSS.t157 VSS 0.09288f
C758 VSS.t159 VSS 0.09288f
C759 VSS.t89 VSS 0.09288f
C760 VSS.t91 VSS 0.09288f
C761 VSS.t281 VSS 0.09466f
C762 VSS.t59 VSS 0.09288f
C763 VSS.t207 VSS 0.0912f
C764 VSS.t105 VSS 0.09295f
C765 VSS.t31 VSS 0.0912f
C766 VSS.t205 VSS 0.0912f
C767 VSS.t109 VSS 0.0912f
C768 VSS.t29 VSS 0.0912f
C769 VSS.t71 VSS 0.0912f
C770 VSS.t107 VSS 0.0912f
C771 VSS.t5 VSS 0.0912f
C772 VSS.t69 VSS 0.0912f
C773 VSS.t35 VSS 0.0912f
C774 VSS.t3 VSS 0.0912f
C775 VSS.t113 VSS 0.0912f
C776 VSS.t33 VSS 0.0912f
C777 VSS.t75 VSS 0.0912f
C778 VSS.t111 VSS 0.0912f
C779 VSS.t9 VSS 0.0912f
C780 VSS.t73 VSS 0.0912f
C781 VSS.t39 VSS 0.0912f
C782 VSS.t7 VSS 0.0912f
C783 VSS.t117 VSS 0.0912f
C784 VSS.t37 VSS 0.0912f
C785 VSS.t179 VSS 0.0912f
C786 VSS.t115 VSS 0.0912f
C787 VSS.t183 VSS 0.0912f
C788 VSS.t177 VSS 0.0912f
C789 VSS.t167 VSS 0.0912f
C790 VSS.t181 VSS 0.0912f
C791 VSS.t79 VSS 0.0912f
C792 VSS.t165 VSS 0.0912f
C793 VSS.t11 VSS 0.09295f
C794 VSS.t77 VSS 0.0912f
C795 VDD.n1 VSS 1.17784f
C796 VDD.t226 VSS 0.64274f
C797 VDD.t228 VSS 0.11467f
C798 VDD.t230 VSS 0.11467f
C799 VDD.t232 VSS 0.64217f
C800 VDD.t264 VSS 0.64217f
C801 VDD.t266 VSS 0.11467f
C802 VDD.t268 VSS 0.11467f
C803 VDD.t270 VSS 0.64217f
C804 VDD.t238 VSS 0.64217f
C805 VDD.t236 VSS 0.11467f
C806 VDD.t224 VSS 0.11467f
C807 VDD.t234 VSS 0.64217f
C808 VDD.t66 VSS 0.64217f
C809 VDD.t180 VSS 0.11467f
C810 VDD.t28 VSS 0.11467f
C811 VDD.t108 VSS 0.11467f
C812 VDD.t100 VSS 0.11467f
C813 VDD.t68 VSS 0.11467f
C814 VDD.t190 VSS 0.11467f
C815 VDD.t274 VSS 0.64217f
C816 VDD.t186 VSS 0.64217f
C817 VDD.t132 VSS 0.11467f
C818 VDD.t134 VSS 0.11467f
C819 VDD.t142 VSS 0.11467f
C820 VDD.t136 VSS 0.11467f
C821 VDD.t154 VSS 0.11467f
C822 VDD.t206 VSS 0.11467f
C823 VDD.t204 VSS 0.64217f
C824 VDD.t92 VSS 0.64217f
C825 VDD.t90 VSS 0.11467f
C826 VDD.t40 VSS 0.11467f
C827 VDD.t38 VSS 0.11467f
C828 VDD.t184 VSS 0.11467f
C829 VDD.t182 VSS 0.11467f
C830 VDD.t2 VSS 0.11467f
C831 VDD.t0 VSS 0.11467f
C832 VDD.t104 VSS 0.11467f
C833 VDD.t102 VSS 0.11467f
C834 VDD.t96 VSS 0.11467f
C835 VDD.t94 VSS 0.64217f
C836 VDD.t62 VSS 0.64217f
C837 VDD.t106 VSS 0.11467f
C838 VDD.t178 VSS 0.11467f
C839 VDD.t198 VSS 0.11467f
C840 VDD.t148 VSS 0.11467f
C841 VDD.t196 VSS 0.11467f
C842 VDD.t176 VSS 0.11467f
C843 VDD.t20 VSS 0.11467f
C844 VDD.t218 VSS 0.11467f
C845 VDD.t18 VSS 0.11467f
C846 VDD.t22 VSS 0.11467f
C847 VDD.t98 VSS 0.11467f
C848 VDD.t84 VSS 0.11467f
C849 VDD.t56 VSS 0.11467f
C850 VDD.t146 VSS 0.11467f
C851 VDD.t140 VSS 0.11467f
C852 VDD.t138 VSS 0.11467f
C853 VDD.t216 VSS 0.11467f
C854 VDD.t214 VSS 0.11467f
C855 VDD.t60 VSS 0.11467f
C856 VDD.t58 VSS 0.11467f
C857 VDD.t26 VSS 0.11467f
C858 VDD.t24 VSS 0.11467f
C859 VDD.t168 VSS 0.11467f
C860 VDD.t166 VSS 0.11467f
C861 VDD.t164 VSS 0.11467f
C862 VDD.t162 VSS 0.11467f
C863 VDD.t16 VSS 0.11467f
C864 VDD.t14 VSS 0.11467f
C865 VDD.t160 VSS 0.11467f
C866 VDD.t158 VSS 0.11467f
C867 VDD.t64 VSS 0.55984f
C868 VDD.n2 VSS 3.17002f
C869 VDD.t107 VSS 0.09943f
C870 VDD.t63 VSS 0.10118f
C871 VDD.n3 VSS 0.04297f
C872 VDD.t199 VSS 0.09943f
C873 VDD.t179 VSS 0.09943f
C874 VDD.n4 VSS 0.04263f
C875 VDD.n5 VSS 0.0216f
C876 VDD.t197 VSS 0.09943f
C877 VDD.t149 VSS 0.09943f
C878 VDD.n6 VSS 0.04263f
C879 VDD.n7 VSS 0.01223f
C880 VDD.t21 VSS 0.09943f
C881 VDD.t177 VSS 0.09943f
C882 VDD.n8 VSS 0.04263f
C883 VDD.n9 VSS 0.01223f
C884 VDD.t19 VSS 0.09943f
C885 VDD.t219 VSS 0.09943f
C886 VDD.n10 VSS 0.04263f
C887 VDD.n11 VSS 0.01223f
C888 VDD.t99 VSS 0.09943f
C889 VDD.t23 VSS 0.09943f
C890 VDD.n12 VSS 0.04263f
C891 VDD.n13 VSS 0.01223f
C892 VDD.t57 VSS 0.09943f
C893 VDD.t85 VSS 0.09943f
C894 VDD.n14 VSS 0.04263f
C895 VDD.n15 VSS 0.01223f
C896 VDD.t141 VSS 0.09943f
C897 VDD.t147 VSS 0.09943f
C898 VDD.n16 VSS 0.04263f
C899 VDD.n17 VSS 0.01223f
C900 VDD.t217 VSS 0.09943f
C901 VDD.t139 VSS 0.09943f
C902 VDD.n18 VSS 0.04263f
C903 VDD.n19 VSS 0.01223f
C904 VDD.t61 VSS 0.09943f
C905 VDD.t215 VSS 0.09943f
C906 VDD.n20 VSS 0.04263f
C907 VDD.n21 VSS 0.01223f
C908 VDD.t27 VSS 0.09943f
C909 VDD.t59 VSS 0.09943f
C910 VDD.n22 VSS 0.04263f
C911 VDD.n23 VSS 0.01223f
C912 VDD.t169 VSS 0.09943f
C913 VDD.t25 VSS 0.09943f
C914 VDD.n24 VSS 0.04263f
C915 VDD.n25 VSS 0.01223f
C916 VDD.t165 VSS 0.09943f
C917 VDD.t167 VSS 0.09943f
C918 VDD.n26 VSS 0.04263f
C919 VDD.n27 VSS 0.01223f
C920 VDD.t17 VSS 0.09943f
C921 VDD.t163 VSS 0.09943f
C922 VDD.n28 VSS 0.04263f
C923 VDD.n29 VSS 0.01223f
C924 VDD.t161 VSS 0.09943f
C925 VDD.t15 VSS 0.09943f
C926 VDD.n30 VSS 0.04263f
C927 VDD.n31 VSS 0.01223f
C928 VDD.t65 VSS 0.10118f
C929 VDD.t159 VSS 0.09943f
C930 VDD.n32 VSS 0.04263f
C931 VDD.n33 VSS 0.04776f
C932 VDD.n34 VSS 0.59102f
C933 VDD.t91 VSS 0.10112f
C934 VDD.t93 VSS 0.1029f
C935 VDD.n35 VSS 0.04297f
C936 VDD.t39 VSS 0.10112f
C937 VDD.t41 VSS 0.10112f
C938 VDD.n36 VSS 0.04263f
C939 VDD.n37 VSS 0.0216f
C940 VDD.t183 VSS 0.10112f
C941 VDD.t185 VSS 0.10112f
C942 VDD.n38 VSS 0.04263f
C943 VDD.n39 VSS 0.01223f
C944 VDD.t1 VSS 0.10112f
C945 VDD.t3 VSS 0.10112f
C946 VDD.n40 VSS 0.04263f
C947 VDD.n41 VSS 0.01223f
C948 VDD.t103 VSS 0.10112f
C949 VDD.t105 VSS 0.10112f
C950 VDD.n42 VSS 0.04263f
C951 VDD.n43 VSS 0.01223f
C952 VDD.t95 VSS 0.1029f
C953 VDD.t97 VSS 0.10112f
C954 VDD.n44 VSS 0.04263f
C955 VDD.n45 VSS 0.04776f
C956 VDD.n46 VSS 0.81963f
C957 VDD.t133 VSS 0.10778f
C958 VDD.t187 VSS 0.10969f
C959 VDD.n47 VSS 0.04297f
C960 VDD.t143 VSS 0.10778f
C961 VDD.t135 VSS 0.10778f
C962 VDD.n48 VSS 0.04263f
C963 VDD.n49 VSS 0.0216f
C964 VDD.t155 VSS 0.10778f
C965 VDD.t137 VSS 0.10778f
C966 VDD.n50 VSS 0.04263f
C967 VDD.n51 VSS 0.01223f
C968 VDD.t205 VSS 0.10969f
C969 VDD.t207 VSS 0.10778f
C970 VDD.n52 VSS 0.04263f
C971 VDD.n53 VSS 0.04776f
C972 VDD.n54 VSS 0.51552f
C973 VDD.t181 VSS 0.10374f
C974 VDD.t67 VSS 0.10558f
C975 VDD.n55 VSS 0.04297f
C976 VDD.t109 VSS 0.10374f
C977 VDD.t29 VSS 0.10374f
C978 VDD.n56 VSS 0.04263f
C979 VDD.n57 VSS 0.0216f
C980 VDD.t69 VSS 0.10374f
C981 VDD.t101 VSS 0.10374f
C982 VDD.n58 VSS 0.04263f
C983 VDD.n59 VSS 0.01223f
C984 VDD.t275 VSS 0.10558f
C985 VDD.t191 VSS 0.10374f
C986 VDD.n60 VSS 0.04263f
C987 VDD.n61 VSS 0.04776f
C988 VDD.n62 VSS 0.46484f
C989 VDD.t237 VSS 0.07999f
C990 VDD.t239 VSS 0.08137f
C991 VDD.n63 VSS 0.04297f
C992 VDD.t235 VSS 0.08137f
C993 VDD.t225 VSS 0.07999f
C994 VDD.n64 VSS 0.04263f
C995 VDD.n65 VSS 0.05713f
C996 VDD.n66 VSS 0.41415f
C997 VDD.t267 VSS 0.07129f
C998 VDD.t265 VSS 0.0725f
C999 VDD.n67 VSS 0.04297f
C1000 VDD.t271 VSS 0.0725f
C1001 VDD.t269 VSS 0.07129f
C1002 VDD.n68 VSS 0.04263f
C1003 VDD.n69 VSS 0.05713f
C1004 VDD.n70 VSS 0.36347f
C1005 VDD.t229 VSS 0.07999f
C1006 VDD.t227 VSS 0.08137f
C1007 VDD.n71 VSS 0.04297f
C1008 VDD.t233 VSS 0.08137f
C1009 VDD.t231 VSS 0.07999f
C1010 VDD.n72 VSS 0.04263f
C1011 VDD.n73 VSS 0.05713f
C1012 VDD.n74 VSS 0.36268f
C1013 VDD.n75 VSS 0.17122f
C1014 VDD.n76 VSS 4.8484f
C1015 VDD.n77 VSS 30.4649f
C1016 VDD.n78 VSS 64.54961f
C1017 VDD.n79 VSS 1.17784f
C1018 VDD.t258 VSS 0.64274f
C1019 VDD.t256 VSS 0.11467f
C1020 VDD.t252 VSS 0.11467f
C1021 VDD.t260 VSS 0.64217f
C1022 VDD.t240 VSS 0.64217f
C1023 VDD.t242 VSS 0.11467f
C1024 VDD.t244 VSS 0.11467f
C1025 VDD.t246 VSS 0.64217f
C1026 VDD.t254 VSS 0.64217f
C1027 VDD.t250 VSS 0.11467f
C1028 VDD.t262 VSS 0.11467f
C1029 VDD.t248 VSS 0.64217f
C1030 VDD.t152 VSS 0.64217f
C1031 VDD.t150 VSS 0.11467f
C1032 VDD.t88 VSS 0.11467f
C1033 VDD.t86 VSS 0.11467f
C1034 VDD.t36 VSS 0.11467f
C1035 VDD.t34 VSS 0.11467f
C1036 VDD.t172 VSS 0.11467f
C1037 VDD.t170 VSS 0.64217f
C1038 VDD.t194 VSS 0.64217f
C1039 VDD.t192 VSS 0.11467f
C1040 VDD.t32 VSS 0.11467f
C1041 VDD.t30 VSS 0.11467f
C1042 VDD.t112 VSS 0.11467f
C1043 VDD.t110 VSS 0.11467f
C1044 VDD.t286 VSS 0.11467f
C1045 VDD.t284 VSS 0.64217f
C1046 VDD.t72 VSS 0.64217f
C1047 VDD.t70 VSS 0.11467f
C1048 VDD.t130 VSS 0.11467f
C1049 VDD.t128 VSS 0.11467f
C1050 VDD.t282 VSS 0.11467f
C1051 VDD.t280 VSS 0.11467f
C1052 VDD.t278 VSS 0.11467f
C1053 VDD.t276 VSS 0.11467f
C1054 VDD.t222 VSS 0.11467f
C1055 VDD.t220 VSS 0.11467f
C1056 VDD.t202 VSS 0.11467f
C1057 VDD.t200 VSS 0.64217f
C1058 VDD.t212 VSS 0.64217f
C1059 VDD.t42 VSS 0.11467f
C1060 VDD.t114 VSS 0.11467f
C1061 VDD.t74 VSS 0.11467f
C1062 VDD.t4 VSS 0.11467f
C1063 VDD.t44 VSS 0.11467f
C1064 VDD.t116 VSS 0.11467f
C1065 VDD.t76 VSS 0.11467f
C1066 VDD.t6 VSS 0.11467f
C1067 VDD.t46 VSS 0.11467f
C1068 VDD.t118 VSS 0.11467f
C1069 VDD.t174 VSS 0.11467f
C1070 VDD.t188 VSS 0.11467f
C1071 VDD.t144 VSS 0.11467f
C1072 VDD.t78 VSS 0.11467f
C1073 VDD.t8 VSS 0.11467f
C1074 VDD.t48 VSS 0.11467f
C1075 VDD.t120 VSS 0.11467f
C1076 VDD.t156 VSS 0.11467f
C1077 VDD.t272 VSS 0.11467f
C1078 VDD.t50 VSS 0.11467f
C1079 VDD.t124 VSS 0.11467f
C1080 VDD.t122 VSS 0.11467f
C1081 VDD.t210 VSS 0.11467f
C1082 VDD.t208 VSS 0.11467f
C1083 VDD.t82 VSS 0.11467f
C1084 VDD.t80 VSS 0.11467f
C1085 VDD.t12 VSS 0.11467f
C1086 VDD.t10 VSS 0.11467f
C1087 VDD.t54 VSS 0.11467f
C1088 VDD.t52 VSS 0.11467f
C1089 VDD.t126 VSS 0.55984f
C1090 VDD.n80 VSS 3.17002f
C1091 VDD.t43 VSS 0.09943f
C1092 VDD.t213 VSS 0.10118f
C1093 VDD.n81 VSS 0.04297f
C1094 VDD.t75 VSS 0.09943f
C1095 VDD.t115 VSS 0.09943f
C1096 VDD.n82 VSS 0.04263f
C1097 VDD.n83 VSS 0.0216f
C1098 VDD.t45 VSS 0.09943f
C1099 VDD.t5 VSS 0.09943f
C1100 VDD.n84 VSS 0.04263f
C1101 VDD.n85 VSS 0.01223f
C1102 VDD.t77 VSS 0.09943f
C1103 VDD.t117 VSS 0.09943f
C1104 VDD.n86 VSS 0.04263f
C1105 VDD.n87 VSS 0.01223f
C1106 VDD.t47 VSS 0.09943f
C1107 VDD.t7 VSS 0.09943f
C1108 VDD.n88 VSS 0.04263f
C1109 VDD.n89 VSS 0.01223f
C1110 VDD.t175 VSS 0.09943f
C1111 VDD.t119 VSS 0.09943f
C1112 VDD.n90 VSS 0.04263f
C1113 VDD.n91 VSS 0.01223f
C1114 VDD.t145 VSS 0.09943f
C1115 VDD.t189 VSS 0.09943f
C1116 VDD.n92 VSS 0.04263f
C1117 VDD.n93 VSS 0.01223f
C1118 VDD.t9 VSS 0.09943f
C1119 VDD.t79 VSS 0.09943f
C1120 VDD.n94 VSS 0.04263f
C1121 VDD.n95 VSS 0.01223f
C1122 VDD.t121 VSS 0.09943f
C1123 VDD.t49 VSS 0.09943f
C1124 VDD.n96 VSS 0.04263f
C1125 VDD.n97 VSS 0.01223f
C1126 VDD.t273 VSS 0.09943f
C1127 VDD.t157 VSS 0.09943f
C1128 VDD.n98 VSS 0.04263f
C1129 VDD.n99 VSS 0.01223f
C1130 VDD.t125 VSS 0.09943f
C1131 VDD.t51 VSS 0.09943f
C1132 VDD.n100 VSS 0.04263f
C1133 VDD.n101 VSS 0.01223f
C1134 VDD.t211 VSS 0.09943f
C1135 VDD.t123 VSS 0.09943f
C1136 VDD.n102 VSS 0.04263f
C1137 VDD.n103 VSS 0.01223f
C1138 VDD.t83 VSS 0.09943f
C1139 VDD.t209 VSS 0.09943f
C1140 VDD.n104 VSS 0.04263f
C1141 VDD.n105 VSS 0.01223f
C1142 VDD.t13 VSS 0.09943f
C1143 VDD.t81 VSS 0.09943f
C1144 VDD.n106 VSS 0.04263f
C1145 VDD.n107 VSS 0.01223f
C1146 VDD.t55 VSS 0.09943f
C1147 VDD.t11 VSS 0.09943f
C1148 VDD.n108 VSS 0.04263f
C1149 VDD.n109 VSS 0.01223f
C1150 VDD.t127 VSS 0.10118f
C1151 VDD.t53 VSS 0.09943f
C1152 VDD.n110 VSS 0.04263f
C1153 VDD.n111 VSS 0.04776f
C1154 VDD.n112 VSS 0.59102f
C1155 VDD.t71 VSS 0.10112f
C1156 VDD.t73 VSS 0.1029f
C1157 VDD.n113 VSS 0.04297f
C1158 VDD.t129 VSS 0.10112f
C1159 VDD.t131 VSS 0.10112f
C1160 VDD.n114 VSS 0.04263f
C1161 VDD.n115 VSS 0.0216f
C1162 VDD.t281 VSS 0.10112f
C1163 VDD.t283 VSS 0.10112f
C1164 VDD.n116 VSS 0.04263f
C1165 VDD.n117 VSS 0.01223f
C1166 VDD.t277 VSS 0.10112f
C1167 VDD.t279 VSS 0.10112f
C1168 VDD.n118 VSS 0.04263f
C1169 VDD.n119 VSS 0.01223f
C1170 VDD.t221 VSS 0.10112f
C1171 VDD.t223 VSS 0.10112f
C1172 VDD.n120 VSS 0.04263f
C1173 VDD.n121 VSS 0.01223f
C1174 VDD.t201 VSS 0.1029f
C1175 VDD.t203 VSS 0.10112f
C1176 VDD.n122 VSS 0.04263f
C1177 VDD.n123 VSS 0.04776f
C1178 VDD.n124 VSS 0.81963f
C1179 VDD.t193 VSS 0.10778f
C1180 VDD.t195 VSS 0.10969f
C1181 VDD.n125 VSS 0.04297f
C1182 VDD.t31 VSS 0.10778f
C1183 VDD.t33 VSS 0.10778f
C1184 VDD.n126 VSS 0.04263f
C1185 VDD.n127 VSS 0.0216f
C1186 VDD.t111 VSS 0.10778f
C1187 VDD.t113 VSS 0.10778f
C1188 VDD.n128 VSS 0.04263f
C1189 VDD.n129 VSS 0.01223f
C1190 VDD.t285 VSS 0.10969f
C1191 VDD.t287 VSS 0.10778f
C1192 VDD.n130 VSS 0.04263f
C1193 VDD.n131 VSS 0.04776f
C1194 VDD.n132 VSS 0.51552f
C1195 VDD.t151 VSS 0.10374f
C1196 VDD.t153 VSS 0.10558f
C1197 VDD.n133 VSS 0.04297f
C1198 VDD.t87 VSS 0.10374f
C1199 VDD.t89 VSS 0.10374f
C1200 VDD.n134 VSS 0.04263f
C1201 VDD.n135 VSS 0.0216f
C1202 VDD.t35 VSS 0.10374f
C1203 VDD.t37 VSS 0.10374f
C1204 VDD.n136 VSS 0.04263f
C1205 VDD.n137 VSS 0.01223f
C1206 VDD.t171 VSS 0.10558f
C1207 VDD.t173 VSS 0.10374f
C1208 VDD.n138 VSS 0.04263f
C1209 VDD.n139 VSS 0.04776f
C1210 VDD.n140 VSS 0.46484f
C1211 VDD.t251 VSS 0.07861f
C1212 VDD.t255 VSS 0.07996f
C1213 VDD.n141 VSS 0.04297f
C1214 VDD.t249 VSS 0.07996f
C1215 VDD.t263 VSS 0.07861f
C1216 VDD.n142 VSS 0.04263f
C1217 VDD.n143 VSS 0.05713f
C1218 VDD.n144 VSS 0.41415f
C1219 VDD.t243 VSS 0.07129f
C1220 VDD.t241 VSS 0.0725f
C1221 VDD.n145 VSS 0.04297f
C1222 VDD.t247 VSS 0.0725f
C1223 VDD.t245 VSS 0.07129f
C1224 VDD.n146 VSS 0.04263f
C1225 VDD.n147 VSS 0.05713f
C1226 VDD.n148 VSS 0.36347f
C1227 VDD.t257 VSS 0.07861f
C1228 VDD.t259 VSS 0.07996f
C1229 VDD.n149 VSS 0.04297f
C1230 VDD.t261 VSS 0.07996f
C1231 VDD.t253 VSS 0.07861f
C1232 VDD.n150 VSS 0.04263f
C1233 VDD.n151 VSS 0.05713f
C1234 VDD.n152 VSS 0.36268f
C1235 VDD.n153 VSS 0.17122f
C1236 VDD.n154 VSS 4.8484f
C1237 VDD.n155 VSS 30.0501f
C1238 VDD.n156 VSS 64.9644f
C1239 VDD.n158 VSS 0.01144f
C1240 CLKN_HB.n0 VSS 0.06668f
C1241 CLKN_HB.n1 VSS 0.0725f
C1242 CLKN_HB.n2 VSS 0.0725f
C1243 CLKN_HB.n3 VSS 0.06668f
C1244 CLKN_HB.n4 VSS 0.31828f
C1245 CLKN_HB.n5 VSS 0.06668f
C1246 CLKN_HB.n6 VSS 0.0725f
C1247 CLKN_HB.n7 VSS 0.0725f
C1248 CLKN_HB.n8 VSS 0.06668f
C1249 CLKN_HB.n9 VSS 0.25723f
C1250 CLKN_HB.n10 VSS 0.84853f
C1251 CLKN_HB.n11 VSS 0.06668f
C1252 CLKN_HB.n12 VSS 0.0725f
C1253 CLKN_HB.n13 VSS 0.0725f
C1254 CLKN_HB.n14 VSS 0.06668f
C1255 CLKN_HB.n15 VSS 0.31828f
C1256 CLKN_HB.n16 VSS 0.06668f
C1257 CLKN_HB.n17 VSS 0.0725f
C1258 CLKN_HB.n18 VSS 0.0725f
C1259 CLKN_HB.n19 VSS 0.06668f
C1260 CLKN_HB.n20 VSS 0.25723f
C1261 CLKN_HB.n21 VSS 0.657f
C1262 CLKN_HB.n22 VSS 1.26044f
C1263 CLKN_H.n0 VSS 0.05975f
C1264 CLKN_H.n1 VSS 0.06497f
C1265 CLKN_H.n2 VSS 0.06497f
C1266 CLKN_H.n3 VSS 0.05975f
C1267 CLKN_H.n4 VSS 0.28519f
C1268 CLKN_H.n5 VSS 0.05975f
C1269 CLKN_H.n6 VSS 0.06497f
C1270 CLKN_H.n7 VSS 0.06497f
C1271 CLKN_H.n8 VSS 0.05975f
C1272 CLKN_H.n9 VSS 0.23049f
C1273 CLKN_H.n10 VSS 1.74315f
C1274 O_CAPTURE_CLKB.t13 VSS 1.05925f
C1275 O_CAPTURE_CLKB.t14 VSS 0.24629f
C1276 O_CAPTURE_CLKB.t0 VSS 0.24629f
C1277 O_CAPTURE_CLKB.n0 VSS 0.78051f
C1278 O_CAPTURE_CLKB.n1 VSS 0.42902f
C1279 O_CAPTURE_CLKB.t1 VSS 0.24629f
C1280 O_CAPTURE_CLKB.t5 VSS 0.24629f
C1281 O_CAPTURE_CLKB.n2 VSS 0.78051f
C1282 O_CAPTURE_CLKB.n3 VSS 0.22396f
C1283 O_CAPTURE_CLKB.t6 VSS 0.24629f
C1284 O_CAPTURE_CLKB.t11 VSS 0.24629f
C1285 O_CAPTURE_CLKB.n4 VSS 0.78051f
C1286 O_CAPTURE_CLKB.n5 VSS 0.22396f
C1287 O_CAPTURE_CLKB.t12 VSS 1.05224f
C1288 O_CAPTURE_CLKB.n6 VSS 0.46336f
C1289 O_CAPTURE_CLKB.t9 VSS 1.05738f
C1290 O_CAPTURE_CLKB.t15 VSS 0.24629f
C1291 O_CAPTURE_CLKB.t3 VSS 0.24629f
C1292 O_CAPTURE_CLKB.n7 VSS 0.77475f
C1293 O_CAPTURE_CLKB.n8 VSS 0.43664f
C1294 O_CAPTURE_CLKB.t2 VSS 0.24629f
C1295 O_CAPTURE_CLKB.t4 VSS 0.24629f
C1296 O_CAPTURE_CLKB.n9 VSS 0.77475f
C1297 O_CAPTURE_CLKB.n10 VSS 0.22971f
C1298 O_CAPTURE_CLKB.t10 VSS 0.24629f
C1299 O_CAPTURE_CLKB.t7 VSS 0.24629f
C1300 O_CAPTURE_CLKB.n11 VSS 0.77475f
C1301 O_CAPTURE_CLKB.n12 VSS 0.22971f
C1302 O_CAPTURE_CLKB.t8 VSS 1.05037f
C1303 O_CAPTURE_CLKB.n13 VSS 0.31419f
C1304 O_CAPTURE_CLKB.n14 VSS 1.0083f
C1305 O_CAPTURE_CLK.t14 VSS 1.02088f
C1306 O_CAPTURE_CLK.t15 VSS 0.24367f
C1307 O_CAPTURE_CLK.t6 VSS 0.24367f
C1308 O_CAPTURE_CLK.n0 VSS 0.74604f
C1309 O_CAPTURE_CLK.n1 VSS 0.41008f
C1310 O_CAPTURE_CLK.t7 VSS 0.24367f
C1311 O_CAPTURE_CLK.t0 VSS 0.24367f
C1312 O_CAPTURE_CLK.n2 VSS 0.74604f
C1313 O_CAPTURE_CLK.n3 VSS 0.21407f
C1314 O_CAPTURE_CLK.t1 VSS 0.24367f
C1315 O_CAPTURE_CLK.t10 VSS 0.24367f
C1316 O_CAPTURE_CLK.n4 VSS 0.74604f
C1317 O_CAPTURE_CLK.n5 VSS 0.21407f
C1318 O_CAPTURE_CLK.t11 VSS 1.01419f
C1319 O_CAPTURE_CLK.n6 VSS 0.4429f
C1320 O_CAPTURE_CLK.t12 VSS 1.0191f
C1321 O_CAPTURE_CLK.t13 VSS 0.24367f
C1322 O_CAPTURE_CLK.t8 VSS 0.24367f
C1323 O_CAPTURE_CLK.n7 VSS 0.74054f
C1324 O_CAPTURE_CLK.n8 VSS 0.41736f
C1325 O_CAPTURE_CLK.t9 VSS 0.24367f
C1326 O_CAPTURE_CLK.t2 VSS 0.24367f
C1327 O_CAPTURE_CLK.n9 VSS 0.74054f
C1328 O_CAPTURE_CLK.n10 VSS 0.21957f
C1329 O_CAPTURE_CLK.t3 VSS 0.24367f
C1330 O_CAPTURE_CLK.t4 VSS 0.24367f
C1331 O_CAPTURE_CLK.n11 VSS 0.74054f
C1332 O_CAPTURE_CLK.n12 VSS 0.21957f
C1333 O_CAPTURE_CLK.t5 VSS 1.0124f
C1334 O_CAPTURE_CLK.n13 VSS 0.30032f
C1335 O_CAPTURE_CLK.n14 VSS 1.53502f
C1336 O_SENSE.t41 VSS 1.09713f
C1337 O_SENSE.t15 VSS 0.24861f
C1338 O_SENSE.t16 VSS 0.24861f
C1339 O_SENSE.n0 VSS 0.81481f
C1340 O_SENSE.n1 VSS 0.44787f
C1341 O_SENSE.t3 VSS 0.24861f
C1342 O_SENSE.t4 VSS 0.24861f
C1343 O_SENSE.n2 VSS 0.81481f
C1344 O_SENSE.n3 VSS 0.2338f
C1345 O_SENSE.t26 VSS 0.24861f
C1346 O_SENSE.t27 VSS 0.24861f
C1347 O_SENSE.n4 VSS 0.81481f
C1348 O_SENSE.n5 VSS 0.2338f
C1349 O_SENSE.t58 VSS 0.24861f
C1350 O_SENSE.t59 VSS 0.24861f
C1351 O_SENSE.n6 VSS 0.81481f
C1352 O_SENSE.n7 VSS 0.2338f
C1353 O_SENSE.t38 VSS 0.24861f
C1354 O_SENSE.t39 VSS 0.24861f
C1355 O_SENSE.n8 VSS 0.81481f
C1356 O_SENSE.n9 VSS 0.2338f
C1357 O_SENSE.t14 VSS 0.24861f
C1358 O_SENSE.t63 VSS 0.24861f
C1359 O_SENSE.n10 VSS 0.81481f
C1360 O_SENSE.n11 VSS 0.2338f
C1361 O_SENSE.t51 VSS 0.24861f
C1362 O_SENSE.t37 VSS 0.24861f
C1363 O_SENSE.n12 VSS 0.81481f
C1364 O_SENSE.n13 VSS 0.2338f
C1365 O_SENSE.t13 VSS 0.24861f
C1366 O_SENSE.t2 VSS 0.24861f
C1367 O_SENSE.n14 VSS 0.81481f
C1368 O_SENSE.n15 VSS 0.2338f
C1369 O_SENSE.t25 VSS 0.24861f
C1370 O_SENSE.t48 VSS 0.24861f
C1371 O_SENSE.n16 VSS 0.81481f
C1372 O_SENSE.n17 VSS 0.2338f
C1373 O_SENSE.t55 VSS 0.24861f
C1374 O_SENSE.t52 VSS 0.24861f
C1375 O_SENSE.n18 VSS 0.81481f
C1376 O_SENSE.n19 VSS 0.2338f
C1377 O_SENSE.t36 VSS 0.24861f
C1378 O_SENSE.t12 VSS 0.24861f
C1379 O_SENSE.n20 VSS 0.81481f
C1380 O_SENSE.n21 VSS 0.2338f
C1381 O_SENSE.t1 VSS 0.24861f
C1382 O_SENSE.t24 VSS 0.24861f
C1383 O_SENSE.n22 VSS 0.81481f
C1384 O_SENSE.n23 VSS 0.2338f
C1385 O_SENSE.t35 VSS 0.24861f
C1386 O_SENSE.t11 VSS 0.24861f
C1387 O_SENSE.n24 VSS 0.81481f
C1388 O_SENSE.n25 VSS 0.2338f
C1389 O_SENSE.t0 VSS 0.24861f
C1390 O_SENSE.t23 VSS 0.24861f
C1391 O_SENSE.n26 VSS 0.81481f
C1392 O_SENSE.n27 VSS 0.2338f
C1393 O_SENSE.t34 VSS 0.24861f
C1394 O_SENSE.t10 VSS 0.24861f
C1395 O_SENSE.n28 VSS 0.81481f
C1396 O_SENSE.n29 VSS 0.2338f
C1397 O_SENSE.t60 VSS 1.08981f
C1398 O_SENSE.n30 VSS 0.48373f
C1399 O_SENSE.t9 VSS 1.09518f
C1400 O_SENSE.t32 VSS 0.24861f
C1401 O_SENSE.t33 VSS 0.24861f
C1402 O_SENSE.n31 VSS 0.8088f
C1403 O_SENSE.n32 VSS 0.45583f
C1404 O_SENSE.t49 VSS 0.24861f
C1405 O_SENSE.t50 VSS 0.24861f
C1406 O_SENSE.n33 VSS 0.8088f
C1407 O_SENSE.n34 VSS 0.23981f
C1408 O_SENSE.t56 VSS 0.24861f
C1409 O_SENSE.t57 VSS 0.24861f
C1410 O_SENSE.n35 VSS 0.8088f
C1411 O_SENSE.n36 VSS 0.23981f
C1412 O_SENSE.t53 VSS 0.24861f
C1413 O_SENSE.t54 VSS 0.24861f
C1414 O_SENSE.n37 VSS 0.8088f
C1415 O_SENSE.n38 VSS 0.23981f
C1416 O_SENSE.t46 VSS 0.24861f
C1417 O_SENSE.t47 VSS 0.24861f
C1418 O_SENSE.n39 VSS 0.8088f
C1419 O_SENSE.n40 VSS 0.23981f
C1420 O_SENSE.t21 VSS 0.24861f
C1421 O_SENSE.t22 VSS 0.24861f
C1422 O_SENSE.n41 VSS 0.8088f
C1423 O_SENSE.n42 VSS 0.23981f
C1424 O_SENSE.t7 VSS 0.24861f
C1425 O_SENSE.t8 VSS 0.24861f
C1426 O_SENSE.n43 VSS 0.8088f
C1427 O_SENSE.n44 VSS 0.23981f
C1428 O_SENSE.t30 VSS 0.24861f
C1429 O_SENSE.t31 VSS 0.24861f
C1430 O_SENSE.n45 VSS 0.8088f
C1431 O_SENSE.n46 VSS 0.23981f
C1432 O_SENSE.t44 VSS 0.24861f
C1433 O_SENSE.t45 VSS 0.24861f
C1434 O_SENSE.n47 VSS 0.8088f
C1435 O_SENSE.n48 VSS 0.23981f
C1436 O_SENSE.t19 VSS 0.24861f
C1437 O_SENSE.t20 VSS 0.24861f
C1438 O_SENSE.n49 VSS 0.8088f
C1439 O_SENSE.n50 VSS 0.23981f
C1440 O_SENSE.t5 VSS 0.24861f
C1441 O_SENSE.t6 VSS 0.24861f
C1442 O_SENSE.n51 VSS 0.8088f
C1443 O_SENSE.n52 VSS 0.23981f
C1444 O_SENSE.t28 VSS 0.24861f
C1445 O_SENSE.t29 VSS 0.24861f
C1446 O_SENSE.n53 VSS 0.8088f
C1447 O_SENSE.n54 VSS 0.23981f
C1448 O_SENSE.t42 VSS 0.24861f
C1449 O_SENSE.t43 VSS 0.24861f
C1450 O_SENSE.n55 VSS 0.8088f
C1451 O_SENSE.n56 VSS 0.23981f
C1452 O_SENSE.t17 VSS 0.24861f
C1453 O_SENSE.t18 VSS 0.24861f
C1454 O_SENSE.n57 VSS 0.8088f
C1455 O_SENSE.n58 VSS 0.23981f
C1456 O_SENSE.t61 VSS 0.24861f
C1457 O_SENSE.t62 VSS 0.24861f
C1458 O_SENSE.n59 VSS 0.8088f
C1459 O_SENSE.n60 VSS 0.23981f
C1460 O_SENSE.t40 VSS 1.08786f
C1461 O_SENSE.n61 VSS 0.328f
C1462 O_SENSE.n62 VSS 2.12935f
C1463 CLKP_HB.n0 VSS 0.06799f
C1464 CLKP_HB.n1 VSS 0.07393f
C1465 CLKP_HB.n2 VSS 0.07393f
C1466 CLKP_HB.n3 VSS 0.06799f
C1467 CLKP_HB.n4 VSS 0.32453f
C1468 CLKP_HB.n5 VSS 0.06799f
C1469 CLKP_HB.n6 VSS 0.07393f
C1470 CLKP_HB.n7 VSS 0.07393f
C1471 CLKP_HB.n8 VSS 0.06799f
C1472 CLKP_HB.n9 VSS 0.26228f
C1473 CLKP_HB.n10 VSS 0.86518f
C1474 CLKP_HB.n11 VSS 0.06799f
C1475 CLKP_HB.n12 VSS 0.07393f
C1476 CLKP_HB.n13 VSS 0.07393f
C1477 CLKP_HB.n14 VSS 0.06799f
C1478 CLKP_HB.n15 VSS 0.32453f
C1479 CLKP_HB.n16 VSS 0.06799f
C1480 CLKP_HB.n17 VSS 0.07393f
C1481 CLKP_HB.n18 VSS 0.07393f
C1482 CLKP_HB.n19 VSS 0.06799f
C1483 CLKP_HB.n20 VSS 0.26228f
C1484 CLKP_HB.n21 VSS 0.66989f
C1485 CLKP_HB.n22 VSS 1.19189f
C1486 CLKP_H.n0 VSS 0.05975f
C1487 CLKP_H.n1 VSS 0.06497f
C1488 CLKP_H.n2 VSS 0.06497f
C1489 CLKP_H.n3 VSS 0.05975f
C1490 CLKP_H.n4 VSS 0.28519f
C1491 CLKP_H.n5 VSS 0.05975f
C1492 CLKP_H.n6 VSS 0.06497f
C1493 CLKP_H.n7 VSS 0.06497f
C1494 CLKP_H.n8 VSS 0.05975f
C1495 CLKP_H.n9 VSS 0.23049f
C1496 CLKP_H.n10 VSS 1.74315f
C1497 E_CAPTURE_CLKB.t14 VSS 1.05925f
C1498 E_CAPTURE_CLKB.t8 VSS 0.24629f
C1499 E_CAPTURE_CLKB.t3 VSS 0.24629f
C1500 E_CAPTURE_CLKB.n0 VSS 0.78051f
C1501 E_CAPTURE_CLKB.n1 VSS 0.42902f
C1502 E_CAPTURE_CLKB.t4 VSS 0.24629f
C1503 E_CAPTURE_CLKB.t5 VSS 0.24629f
C1504 E_CAPTURE_CLKB.n2 VSS 0.78051f
C1505 E_CAPTURE_CLKB.n3 VSS 0.22396f
C1506 E_CAPTURE_CLKB.t0 VSS 0.24629f
C1507 E_CAPTURE_CLKB.t7 VSS 0.24629f
C1508 E_CAPTURE_CLKB.n4 VSS 0.78051f
C1509 E_CAPTURE_CLKB.n5 VSS 0.22396f
C1510 E_CAPTURE_CLKB.t2 VSS 1.05224f
C1511 E_CAPTURE_CLKB.n6 VSS 0.46336f
C1512 E_CAPTURE_CLKB.t13 VSS 1.05738f
C1513 E_CAPTURE_CLKB.t11 VSS 0.24629f
C1514 E_CAPTURE_CLKB.t12 VSS 0.24629f
C1515 E_CAPTURE_CLKB.n7 VSS 0.77475f
C1516 E_CAPTURE_CLKB.n8 VSS 0.43664f
C1517 E_CAPTURE_CLKB.t15 VSS 0.24629f
C1518 E_CAPTURE_CLKB.t6 VSS 0.24629f
C1519 E_CAPTURE_CLKB.n9 VSS 0.77475f
C1520 E_CAPTURE_CLKB.n10 VSS 0.22971f
C1521 E_CAPTURE_CLKB.t10 VSS 0.24629f
C1522 E_CAPTURE_CLKB.t1 VSS 0.24629f
C1523 E_CAPTURE_CLKB.n11 VSS 0.77475f
C1524 E_CAPTURE_CLKB.n12 VSS 0.22971f
C1525 E_CAPTURE_CLKB.t9 VSS 1.05037f
C1526 E_CAPTURE_CLKB.n13 VSS 0.31419f
C1527 E_CAPTURE_CLKB.n14 VSS 1.0083f
C1528 E_CAPTURE_CLK.t11 VSS 1.02088f
C1529 E_CAPTURE_CLK.t12 VSS 0.24367f
C1530 E_CAPTURE_CLK.t6 VSS 0.24367f
C1531 E_CAPTURE_CLK.n0 VSS 0.74604f
C1532 E_CAPTURE_CLK.n1 VSS 0.41008f
C1533 E_CAPTURE_CLK.t4 VSS 0.24367f
C1534 E_CAPTURE_CLK.t5 VSS 0.24367f
C1535 E_CAPTURE_CLK.n2 VSS 0.74604f
C1536 E_CAPTURE_CLK.n3 VSS 0.21407f
C1537 E_CAPTURE_CLK.t3 VSS 0.24367f
C1538 E_CAPTURE_CLK.t0 VSS 0.24367f
C1539 E_CAPTURE_CLK.n4 VSS 0.74604f
C1540 E_CAPTURE_CLK.n5 VSS 0.21407f
C1541 E_CAPTURE_CLK.t7 VSS 1.01419f
C1542 E_CAPTURE_CLK.n6 VSS 0.4429f
C1543 E_CAPTURE_CLK.t13 VSS 1.0191f
C1544 E_CAPTURE_CLK.t14 VSS 0.24367f
C1545 E_CAPTURE_CLK.t15 VSS 0.24367f
C1546 E_CAPTURE_CLK.n7 VSS 0.74054f
C1547 E_CAPTURE_CLK.n8 VSS 0.41736f
C1548 E_CAPTURE_CLK.t1 VSS 0.24367f
C1549 E_CAPTURE_CLK.t2 VSS 0.24367f
C1550 E_CAPTURE_CLK.n9 VSS 0.74054f
C1551 E_CAPTURE_CLK.n10 VSS 0.21957f
C1552 E_CAPTURE_CLK.t8 VSS 0.24367f
C1553 E_CAPTURE_CLK.t9 VSS 0.24367f
C1554 E_CAPTURE_CLK.n11 VSS 0.74054f
C1555 E_CAPTURE_CLK.n12 VSS 0.21957f
C1556 E_CAPTURE_CLK.t10 VSS 1.0124f
C1557 E_CAPTURE_CLK.n13 VSS 0.30032f
C1558 E_CAPTURE_CLK.n14 VSS 1.53502f
C1559 E_SENSE.t20 VSS 1.09713f
C1560 E_SENSE.t42 VSS 0.24861f
C1561 E_SENSE.t43 VSS 0.24861f
C1562 E_SENSE.n0 VSS 0.81481f
C1563 E_SENSE.n1 VSS 0.44787f
C1564 E_SENSE.t2 VSS 0.24861f
C1565 E_SENSE.t3 VSS 0.24861f
C1566 E_SENSE.n2 VSS 0.81481f
C1567 E_SENSE.n3 VSS 0.2338f
C1568 E_SENSE.t44 VSS 0.24861f
C1569 E_SENSE.t45 VSS 0.24861f
C1570 E_SENSE.n4 VSS 0.81481f
C1571 E_SENSE.n5 VSS 0.2338f
C1572 E_SENSE.t46 VSS 0.24861f
C1573 E_SENSE.t47 VSS 0.24861f
C1574 E_SENSE.n6 VSS 0.81481f
C1575 E_SENSE.n7 VSS 0.2338f
C1576 E_SENSE.t7 VSS 0.24861f
C1577 E_SENSE.t8 VSS 0.24861f
C1578 E_SENSE.n8 VSS 0.81481f
C1579 E_SENSE.n9 VSS 0.2338f
C1580 E_SENSE.t16 VSS 0.24861f
C1581 E_SENSE.t17 VSS 0.24861f
C1582 E_SENSE.n10 VSS 0.81481f
C1583 E_SENSE.n11 VSS 0.2338f
C1584 E_SENSE.t54 VSS 0.24861f
C1585 E_SENSE.t55 VSS 0.24861f
C1586 E_SENSE.n12 VSS 0.81481f
C1587 E_SENSE.n13 VSS 0.2338f
C1588 E_SENSE.t38 VSS 0.24861f
C1589 E_SENSE.t39 VSS 0.24861f
C1590 E_SENSE.n14 VSS 0.81481f
C1591 E_SENSE.n15 VSS 0.2338f
C1592 E_SENSE.t40 VSS 0.24861f
C1593 E_SENSE.t15 VSS 0.24861f
C1594 E_SENSE.n16 VSS 0.81481f
C1595 E_SENSE.n17 VSS 0.2338f
C1596 E_SENSE.t25 VSS 0.24861f
C1597 E_SENSE.t26 VSS 0.24861f
C1598 E_SENSE.n18 VSS 0.81481f
C1599 E_SENSE.n19 VSS 0.2338f
C1600 E_SENSE.t6 VSS 0.24861f
C1601 E_SENSE.t4 VSS 0.24861f
C1602 E_SENSE.n20 VSS 0.81481f
C1603 E_SENSE.n21 VSS 0.2338f
C1604 E_SENSE.t56 VSS 0.24861f
C1605 E_SENSE.t5 VSS 0.24861f
C1606 E_SENSE.n22 VSS 0.81481f
C1607 E_SENSE.n23 VSS 0.2338f
C1608 E_SENSE.t48 VSS 0.24861f
C1609 E_SENSE.t52 VSS 0.24861f
C1610 E_SENSE.n24 VSS 0.81481f
C1611 E_SENSE.n25 VSS 0.2338f
C1612 E_SENSE.t41 VSS 0.24861f
C1613 E_SENSE.t53 VSS 0.24861f
C1614 E_SENSE.n26 VSS 0.81481f
C1615 E_SENSE.n27 VSS 0.2338f
C1616 E_SENSE.t49 VSS 0.24861f
C1617 E_SENSE.t27 VSS 0.24861f
C1618 E_SENSE.n28 VSS 0.81481f
C1619 E_SENSE.n29 VSS 0.2338f
C1620 E_SENSE.t18 VSS 1.08981f
C1621 E_SENSE.n30 VSS 0.48373f
C1622 E_SENSE.t61 VSS 1.09518f
C1623 E_SENSE.t50 VSS 0.24861f
C1624 E_SENSE.t51 VSS 0.24861f
C1625 E_SENSE.n31 VSS 0.8088f
C1626 E_SENSE.n32 VSS 0.45583f
C1627 E_SENSE.t34 VSS 0.24861f
C1628 E_SENSE.t35 VSS 0.24861f
C1629 E_SENSE.n33 VSS 0.8088f
C1630 E_SENSE.n34 VSS 0.23981f
C1631 E_SENSE.t13 VSS 0.24861f
C1632 E_SENSE.t14 VSS 0.24861f
C1633 E_SENSE.n35 VSS 0.8088f
C1634 E_SENSE.n36 VSS 0.23981f
C1635 E_SENSE.t0 VSS 0.24861f
C1636 E_SENSE.t1 VSS 0.24861f
C1637 E_SENSE.n37 VSS 0.8088f
C1638 E_SENSE.n38 VSS 0.23981f
C1639 E_SENSE.t23 VSS 0.24861f
C1640 E_SENSE.t24 VSS 0.24861f
C1641 E_SENSE.n39 VSS 0.8088f
C1642 E_SENSE.n40 VSS 0.23981f
C1643 E_SENSE.t32 VSS 0.24861f
C1644 E_SENSE.t33 VSS 0.24861f
C1645 E_SENSE.n41 VSS 0.8088f
C1646 E_SENSE.n42 VSS 0.23981f
C1647 E_SENSE.t11 VSS 0.24861f
C1648 E_SENSE.t12 VSS 0.24861f
C1649 E_SENSE.n43 VSS 0.8088f
C1650 E_SENSE.n44 VSS 0.23981f
C1651 E_SENSE.t36 VSS 0.24861f
C1652 E_SENSE.t37 VSS 0.24861f
C1653 E_SENSE.n45 VSS 0.8088f
C1654 E_SENSE.n46 VSS 0.23981f
C1655 E_SENSE.t30 VSS 0.24861f
C1656 E_SENSE.t31 VSS 0.24861f
C1657 E_SENSE.n47 VSS 0.8088f
C1658 E_SENSE.n48 VSS 0.23981f
C1659 E_SENSE.t9 VSS 0.24861f
C1660 E_SENSE.t10 VSS 0.24861f
C1661 E_SENSE.n49 VSS 0.8088f
C1662 E_SENSE.n50 VSS 0.23981f
C1663 E_SENSE.t59 VSS 0.24861f
C1664 E_SENSE.t60 VSS 0.24861f
C1665 E_SENSE.n51 VSS 0.8088f
C1666 E_SENSE.n52 VSS 0.23981f
C1667 E_SENSE.t21 VSS 0.24861f
C1668 E_SENSE.t22 VSS 0.24861f
C1669 E_SENSE.n53 VSS 0.8088f
C1670 E_SENSE.n54 VSS 0.23981f
C1671 E_SENSE.t62 VSS 0.24861f
C1672 E_SENSE.t63 VSS 0.24861f
C1673 E_SENSE.n55 VSS 0.8088f
C1674 E_SENSE.n56 VSS 0.23981f
C1675 E_SENSE.t57 VSS 0.24861f
C1676 E_SENSE.t58 VSS 0.24861f
C1677 E_SENSE.n57 VSS 0.8088f
C1678 E_SENSE.n58 VSS 0.23981f
C1679 E_SENSE.t28 VSS 0.24861f
C1680 E_SENSE.t29 VSS 0.24861f
C1681 E_SENSE.n59 VSS 0.8088f
C1682 E_SENSE.n60 VSS 0.23981f
C1683 E_SENSE.t19 VSS 1.08786f
C1684 E_SENSE.n61 VSS 0.328f
C1685 E_SENSE.n62 VSS 2.12935f
.ends
