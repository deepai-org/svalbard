* PEX produced using /foss/tools/sak/sak-pex.sh with m=3 and s=1 (extresist threshold=0 mOhm, minres=1 mOhm, mindelay=0 ps)
* NGSPICE file created from local_clock_fanout_pex.ext - technology: gf180mcuD

.subckt local_clock_fanout_pex CLKP_H CLKP_HB CLKN_H CLKN_HB VDD VSS E_SENSE E_CAPTURE_CLK
+ E_CAPTURE_CLKB O_SENSE O_CAPTURE_CLK O_CAPTURE_CLKB
X0 O_SENSE.t42 a_15180_41600.t52 VSS.t245 VSS.t244 nfet_03v3 ad=2.08p pd=8.52u as=2.08p ps=8.52u w=8u l=0.28u
X1 E_CAPTURE_CLKB.t0 a_2700_6400.t12 VSS.t45 VSS.t44 nfet_03v3 ad=2.08p pd=8.52u as=2.08p ps=8.52u w=8u l=0.28u
X2 a_6924_41600.t13 CLKN_HB.t2 VSS.t143 VSS.t142 nfet_03v3 ad=2.08p pd=8.52u as=2.08p ps=8.52u w=8u l=0.28u
X3 VDD.t261 a_2700_6400.t21 E_CAPTURE_CLKB.t9 VDD.t260 pfet_03v3 ad=2.08p pd=8.52u as=2.08p ps=8.52u w=8u l=0.28u
X4 VDD.t181 a_15180_6400.t99 E_SENSE.t48 VDD.t180 pfet_03v3 ad=2.08p pd=8.52u as=2.08p ps=8.52u w=8u l=0.28u
X5 VDD.t77 a_2700_41600.t23 O_CAPTURE_CLKB.t8 VDD.t76 pfet_03v3 ad=2.08p pd=8.52u as=3.52p ps=16.88u w=8u l=0.28u
X6 VSS.t93 a_6924_6400.t35 a_15180_6400.t10 VSS.t92 nfet_03v3 ad=2.08p pd=8.52u as=2.08p ps=8.52u w=8u l=0.28u
X7 O_SENSE.t0 a_15180_41600.t104 VDD.t1 VDD.t0 pfet_03v3 ad=2.08p pd=8.52u as=2.08p ps=8.52u w=8u l=0.28u
X8 VSS.t277 a_15180_41600.t61 O_SENSE.t49 VSS.t276 nfet_03v3 ad=2.08p pd=8.52u as=2.08p ps=8.52u w=8u l=0.28u
X9 E_SENSE.t59 a_15180_6400.t58 VSS.t219 VSS.t218 nfet_03v3 ad=2.08p pd=8.52u as=2.08p ps=8.52u w=8u l=0.28u
X10 O_CAPTURE_CLKB.t2 a_2700_41600.t14 VSS.t29 VSS.t28 nfet_03v3 ad=2.08p pd=8.52u as=2.08p ps=8.52u w=8u l=0.28u
X11 a_15180_6400.t1 a_6924_6400.t60 VDD.t9 VDD.t8 pfet_03v3 ad=2.08p pd=8.52u as=2.08p ps=8.52u w=8u l=0.28u
X12 VSS.t177 a_6924_6400.t33 a_15180_6400.t17 VSS.t176 nfet_03v3 ad=2.08p pd=8.52u as=2.08p ps=8.52u w=8u l=0.28u
X13 VSS.t309 CLKP_HB.t5 a_6924_6400.t10 VSS.t308 nfet_03v3 ad=2.08p pd=8.52u as=2.08p ps=8.52u w=8u l=0.28u
X14 VDD.t169 a_15180_41600.t91 O_SENSE.t26 VDD.t168 pfet_03v3 ad=2.08p pd=8.52u as=2.08p ps=8.52u w=8u l=0.28u
X15 a_6924_6400.t1 CLKP_HB.t18 VDD.t311 VDD.t310 pfet_03v3 ad=2.08p pd=8.52u as=2.08p ps=8.52u w=8u l=0.28u
X16 a_15180_6400.t32 a_6924_6400.t58 VDD.t279 VDD.t278 pfet_03v3 ad=2.08p pd=8.52u as=2.08p ps=8.52u w=8u l=0.28u
X17 VDD.t269 a_15180_6400.t91 E_SENSE.t62 VDD.t268 pfet_03v3 ad=2.08p pd=8.52u as=2.08p ps=8.52u w=8u l=0.28u
X18 E_SENSE.t29 a_15180_6400.t56 VSS.t117 VSS.t116 nfet_03v3 ad=2.08p pd=8.52u as=2.08p ps=8.52u w=8u l=0.28u
X19 O_SENSE.t12 a_15180_41600.t58 VSS.t65 VSS.t64 nfet_03v3 ad=2.08p pd=8.52u as=2.08p ps=8.52u w=8u l=0.28u
X20 VSS.t153 a_6924_41600.t21 a_15180_41600.t21 VSS.t152 nfet_03v3 ad=2.08p pd=8.52u as=2.08p ps=8.52u w=8u l=0.28u
X21 E_CAPTURE_CLKB.t15 a_2700_6400.t16 VDD.t351 VDD.t350 pfet_03v3 ad=3.52p pd=16.88u as=2.08p ps=8.52u w=8u l=0.28u
X22 O_SENSE.t53 a_15180_41600.t110 VDD.t323 VDD.t322 pfet_03v3 ad=2.08p pd=8.52u as=2.08p ps=8.52u w=8u l=0.28u
X23 VDD.t309 CLKP_HB.t19 a_6924_6400.t0 VDD.t308 pfet_03v3 ad=2.08p pd=8.52u as=3.52p ps=16.88u w=8u l=0.28u
X24 E_SENSE.t63 a_15180_6400.t92 VDD.t271 VDD.t270 pfet_03v3 ad=2.08p pd=8.52u as=2.08p ps=8.52u w=8u l=0.28u
X25 VSS.t217 a_15180_6400.t57 E_SENSE.t58 VSS.t216 nfet_03v3 ad=2.08p pd=8.52u as=2.08p ps=8.52u w=8u l=0.28u
X26 VSS.t103 a_15180_6400.t79 E_SENSE.t22 VSS.t102 nfet_03v3 ad=2.08p pd=8.52u as=3.52p ps=16.88u w=8u l=0.28u
X27 VDD.t199 a_6924_41600.t43 a_15180_41600.t25 VDD.t198 pfet_03v3 ad=2.08p pd=8.52u as=2.08p ps=8.52u w=8u l=0.28u
X28 VSS.t259 a_15180_41600.t77 O_SENSE.t44 VSS.t258 nfet_03v3 ad=2.08p pd=8.52u as=2.08p ps=8.52u w=8u l=0.28u
X29 VDD.t317 CLKP_HB.t13 a_6924_6400.t6 VDD.t316 pfet_03v3 ad=2.08p pd=8.52u as=2.08p ps=8.52u w=8u l=0.28u
X30 VDD.t281 a_6924_6400.t53 a_15180_6400.t33 VDD.t280 pfet_03v3 ad=2.08p pd=8.52u as=2.08p ps=8.52u w=8u l=0.28u
X31 a_15180_6400.t42 a_6924_6400.t26 VSS.t293 VSS.t292 nfet_03v3 ad=2.08p pd=8.52u as=2.08p ps=8.52u w=8u l=0.28u
X32 O_CAPTURE_CLK.t8 a_4812_41600.t18 VDD.t245 VDD.t244 pfet_03v3 ad=2.08p pd=8.52u as=2.08p ps=8.52u w=8u l=0.28u
X33 a_15180_41600.t10 a_6924_41600.t18 VSS.t83 VSS.t82 nfet_03v3 ad=2.08p pd=8.52u as=2.08p ps=8.52u w=8u l=0.28u
X34 O_SENSE.t3 a_15180_41600.t64 VSS.t1 VSS.t0 nfet_03v3 ad=2.08p pd=8.52u as=2.08p ps=8.52u w=8u l=0.28u
X35 VDD.t233 a_2700_6400.t17 E_CAPTURE_CLKB.t7 VDD.t232 pfet_03v3 ad=2.08p pd=8.52u as=2.08p ps=8.52u w=8u l=0.28u
X36 VDD.t147 a_6924_6400.t51 a_15180_6400.t23 VDD.t146 pfet_03v3 ad=2.08p pd=8.52u as=2.08p ps=8.52u w=8u l=0.28u
X37 VSS.t55 a_15180_6400.t49 E_SENSE.t14 VSS.t54 nfet_03v3 ad=2.08p pd=8.52u as=2.08p ps=8.52u w=8u l=0.28u
X38 E_CAPTURE_CLK.t1 a_4812_6400.t12 VSS.t27 VSS.t26 nfet_03v3 ad=2.08p pd=8.52u as=2.08p ps=8.52u w=8u l=0.28u
X39 a_15180_41600.t31 a_6924_41600.t40 VDD.t219 VDD.t218 pfet_03v3 ad=3.52p pd=16.88u as=2.08p ps=8.52u w=8u l=0.28u
X40 VDD.t227 a_15180_41600.t83 O_SENSE.t41 VDD.t226 pfet_03v3 ad=2.08p pd=8.52u as=2.08p ps=8.52u w=8u l=0.28u
X41 a_15180_41600.t16 a_6924_41600.t62 VDD.t129 VDD.t128 pfet_03v3 ad=2.08p pd=8.52u as=2.08p ps=8.52u w=8u l=0.28u
X42 VSS.t337 a_6924_41600.t27 a_15180_41600.t46 VSS.t336 nfet_03v3 ad=2.08p pd=8.52u as=2.08p ps=8.52u w=8u l=0.28u
X43 O_CAPTURE_CLKB.t0 a_2700_41600.t20 VDD.t23 VDD.t22 pfet_03v3 ad=2.08p pd=8.52u as=2.08p ps=8.52u w=8u l=0.28u
X44 O_SENSE.t60 a_15180_41600.t50 VSS.t343 VSS.t342 nfet_03v3 ad=2.08p pd=8.52u as=2.08p ps=8.52u w=8u l=0.28u
X45 a_6924_6400.t5 CLKP_HB.t14 VDD.t315 VDD.t314 pfet_03v3 ad=2.08p pd=8.52u as=2.08p ps=8.52u w=8u l=0.28u
X46 a_15180_6400.t34 a_6924_6400.t54 VDD.t283 VDD.t282 pfet_03v3 ad=2.08p pd=8.52u as=2.08p ps=8.52u w=8u l=0.28u
X47 E_SENSE.t45 a_15180_6400.t52 VSS.t203 VSS.t202 nfet_03v3 ad=2.08p pd=8.52u as=2.08p ps=8.52u w=8u l=0.28u
X48 a_6924_41600.t15 CLKN_HB.t0 VSS.t147 VSS.t146 nfet_03v3 ad=3.52p pd=16.88u as=2.08p ps=8.52u w=8u l=0.28u
X49 E_SENSE.t15 a_15180_6400.t50 VSS.t57 VSS.t56 nfet_03v3 ad=2.08p pd=8.52u as=2.08p ps=8.52u w=8u l=0.28u
X50 VDD.t35 a_15180_6400.t85 E_SENSE.t4 VDD.t34 pfet_03v3 ad=2.08p pd=8.52u as=2.08p ps=8.52u w=8u l=0.28u
X51 O_SENSE.t27 a_15180_41600.t80 VDD.t171 VDD.t170 pfet_03v3 ad=3.52p pd=16.88u as=2.08p ps=8.52u w=8u l=0.28u
X52 VSS.t35 a_2700_41600.t11 O_CAPTURE_CLKB.t5 VSS.t34 nfet_03v3 ad=2.08p pd=8.52u as=2.08p ps=8.52u w=8u l=0.28u
X53 a_6924_6400.t7 CLKP_HB.t12 VDD.t319 VDD.t318 pfet_03v3 ad=3.52p pd=16.88u as=2.08p ps=8.52u w=8u l=0.28u
X54 a_15180_6400.t24 a_6924_6400.t52 VDD.t149 VDD.t148 pfet_03v3 ad=2.08p pd=8.52u as=2.08p ps=8.52u w=8u l=0.28u
X55 VSS.t181 a_4812_6400.t13 E_CAPTURE_CLK.t5 VSS.t180 nfet_03v3 ad=2.08p pd=8.52u as=2.08p ps=8.52u w=8u l=0.28u
X56 VDD.t211 a_6924_41600.t59 a_15180_41600.t28 VDD.t210 pfet_03v3 ad=2.08p pd=8.52u as=2.08p ps=8.52u w=8u l=0.28u
X57 O_SENSE.t19 a_15180_41600.t102 VDD.t137 VDD.t136 pfet_03v3 ad=2.08p pd=8.52u as=2.08p ps=8.52u w=8u l=0.28u
X58 a_15180_41600.t5 a_6924_41600.t24 VSS.t23 VSS.t22 nfet_03v3 ad=2.08p pd=8.52u as=2.08p ps=8.52u w=8u l=0.28u
X59 E_CAPTURE_CLK.t10 a_4812_6400.t22 VDD.t275 VDD.t274 pfet_03v3 ad=2.08p pd=8.52u as=2.08p ps=8.52u w=8u l=0.28u
X60 VSS.t231 a_4812_6400.t11 E_CAPTURE_CLK.t8 VSS.t230 nfet_03v3 ad=2.08p pd=8.52u as=2.08p ps=8.52u w=8u l=0.28u
X61 VDD.t165 a_15180_6400.t83 E_SENSE.t36 VDD.t164 pfet_03v3 ad=2.08p pd=8.52u as=2.08p ps=8.52u w=8u l=0.28u
X62 VDD.t81 a_2700_41600.t17 O_CAPTURE_CLKB.t10 VDD.t80 pfet_03v3 ad=2.08p pd=8.52u as=2.08p ps=8.52u w=8u l=0.28u
X63 a_15180_41600.t36 a_6924_41600.t46 VDD.t243 VDD.t242 pfet_03v3 ad=2.08p pd=8.52u as=2.08p ps=8.52u w=8u l=0.28u
X64 a_4812_41600.t5 CLKN_H.t2 VSS.t7 VSS.t6 nfet_03v3 ad=2.08p pd=8.52u as=2.08p ps=8.52u w=8u l=0.28u
X65 a_15180_6400.t36 a_6924_6400.t46 VDD.t287 VDD.t286 pfet_03v3 ad=2.08p pd=8.52u as=2.08p ps=8.52u w=8u l=0.28u
X66 VSS.t281 a_6924_6400.t19 a_15180_6400.t37 VSS.t280 nfet_03v3 ad=2.08p pd=8.52u as=2.08p ps=8.52u w=8u l=0.28u
X67 VSS.t243 a_4812_41600.t15 O_CAPTURE_CLK.t3 VSS.t242 nfet_03v3 ad=2.08p pd=8.52u as=3.52p ps=16.88u w=8u l=0.28u
X68 a_4812_41600.t3 CLKN_H.t4 VDD.t17 VDD.t16 pfet_03v3 ad=3.52p pd=16.88u as=2.08p ps=8.52u w=8u l=0.28u
X69 O_SENSE.t34 a_15180_41600.t56 VSS.t227 VSS.t226 nfet_03v3 ad=2.08p pd=8.52u as=2.08p ps=8.52u w=8u l=0.28u
X70 VSS.t209 a_15180_6400.t73 E_SENSE.t54 VSS.t208 nfet_03v3 ad=2.08p pd=8.52u as=2.08p ps=8.52u w=8u l=0.28u
X71 E_CAPTURE_CLKB.t11 a_2700_6400.t14 VSS.t341 VSS.t340 nfet_03v3 ad=2.08p pd=8.52u as=2.08p ps=8.52u w=8u l=0.28u
X72 VDD.t237 a_4812_41600.t21 O_CAPTURE_CLK.t5 VDD.t236 pfet_03v3 ad=2.08p pd=8.52u as=2.08p ps=8.52u w=8u l=0.28u
X73 VDD.t3 a_15180_41600.t99 O_SENSE.t1 VDD.t2 pfet_03v3 ad=2.08p pd=8.52u as=2.08p ps=8.52u w=8u l=0.28u
X74 VSS.t133 CLKN_HB.t9 a_2700_41600.t6 VSS.t132 nfet_03v3 ad=2.08p pd=8.52u as=2.08p ps=8.52u w=8u l=0.28u
X75 a_6924_41600.t9 CLKN_HB.t6 VSS.t137 VSS.t136 nfet_03v3 ad=2.08p pd=8.52u as=2.08p ps=8.52u w=8u l=0.28u
X76 VDD.t349 a_2700_6400.t23 E_CAPTURE_CLKB.t14 VDD.t348 pfet_03v3 ad=2.08p pd=8.52u as=3.52p ps=16.88u w=8u l=0.28u
X77 O_SENSE.t38 a_15180_41600.t86 VDD.t215 VDD.t214 pfet_03v3 ad=2.08p pd=8.52u as=2.08p ps=8.52u w=8u l=0.28u
X78 VDD.t143 a_4812_6400.t23 E_CAPTURE_CLK.t4 VDD.t142 pfet_03v3 ad=2.08p pd=8.52u as=3.52p ps=16.88u w=8u l=0.28u
X79 E_SENSE.t1 a_15180_6400.t106 VDD.t29 VDD.t28 pfet_03v3 ad=2.08p pd=8.52u as=2.08p ps=8.52u w=8u l=0.28u
X80 a_2700_6400.t5 CLKP_HB.t10 VSS.t299 VSS.t298 nfet_03v3 ad=2.08p pd=8.52u as=2.08p ps=8.52u w=8u l=0.28u
X81 a_6924_41600.t3 CLKN_HB.t16 VDD.t121 VDD.t120 pfet_03v3 ad=2.08p pd=8.52u as=2.08p ps=8.52u w=8u l=0.28u
X82 O_SENSE.t48 a_15180_41600.t108 VDD.t253 VDD.t252 pfet_03v3 ad=2.08p pd=8.52u as=2.08p ps=8.52u w=8u l=0.28u
X83 VDD.t299 CLKP_HB.t23 a_2700_6400.t0 VDD.t298 pfet_03v3 ad=2.08p pd=8.52u as=3.52p ps=16.88u w=8u l=0.28u
X84 VDD.t289 a_6924_6400.t47 a_15180_6400.t39 VDD.t288 pfet_03v3 ad=2.08p pd=8.52u as=2.08p ps=8.52u w=8u l=0.28u
X85 a_15180_6400.t38 a_6924_6400.t20 VSS.t283 VSS.t282 nfet_03v3 ad=2.08p pd=8.52u as=2.08p ps=8.52u w=8u l=0.28u
X86 a_2700_6400.t7 CLKP_HB.t8 VSS.t303 VSS.t302 nfet_03v3 ad=3.52p pd=16.88u as=2.08p ps=8.52u w=8u l=0.28u
X87 VSS.t235 a_15180_41600.t53 O_SENSE.t39 VSS.t234 nfet_03v3 ad=2.08p pd=8.52u as=2.08p ps=8.52u w=8u l=0.28u
X88 VDD.t285 a_6924_6400.t45 a_15180_6400.t35 VDD.t284 pfet_03v3 ad=2.08p pd=8.52u as=2.08p ps=8.52u w=8u l=0.28u
X89 VSS.t141 CLKN_HB.t3 a_6924_41600.t12 VSS.t140 nfet_03v3 ad=2.08p pd=8.52u as=2.08p ps=8.52u w=8u l=0.28u
X90 VSS.t59 a_15180_41600.t75 O_SENSE.t9 VSS.t58 nfet_03v3 ad=2.08p pd=8.52u as=2.08p ps=8.52u w=8u l=0.28u
X91 VDD.t177 a_15180_6400.t109 E_SENSE.t46 VDD.t176 pfet_03v3 ad=2.08p pd=8.52u as=2.08p ps=8.52u w=8u l=0.28u
X92 VDD.t83 a_15180_6400.t107 E_SENSE.t16 VDD.t82 pfet_03v3 ad=2.08p pd=8.52u as=2.08p ps=8.52u w=8u l=0.28u
X93 a_4812_6400.t7 CLKP_H.t0 VSS.t75 VSS.t74 nfet_03v3 ad=3.52p pd=16.88u as=2.08p ps=8.52u w=8u l=0.28u
X94 VDD.t125 CLKN_HB.t13 a_6924_41600.t6 VDD.t124 pfet_03v3 ad=2.08p pd=8.52u as=2.08p ps=8.52u w=8u l=0.28u
X95 VDD.t69 a_15180_41600.t105 O_SENSE.t13 VDD.t68 pfet_03v3 ad=2.08p pd=8.52u as=2.08p ps=8.52u w=8u l=0.28u
X96 VSS.t31 a_2700_41600.t15 O_CAPTURE_CLKB.t3 VSS.t30 nfet_03v3 ad=2.08p pd=8.52u as=3.52p ps=16.88u w=8u l=0.28u
X97 VSS.t301 CLKP_HB.t9 a_2700_6400.t6 VSS.t300 nfet_03v3 ad=2.08p pd=8.52u as=2.08p ps=8.52u w=8u l=0.28u
X98 O_SENSE.t63 a_15180_41600.t72 VSS.t347 VSS.t346 nfet_03v3 ad=2.08p pd=8.52u as=2.08p ps=8.52u w=8u l=0.28u
X99 E_SENSE.t57 a_15180_6400.t66 VSS.t215 VSS.t214 nfet_03v3 ad=2.08p pd=8.52u as=2.08p ps=8.52u w=8u l=0.28u
X100 VSS.t69 CLKP_H.t3 a_4812_6400.t4 VSS.t68 nfet_03v3 ad=2.08p pd=8.52u as=3.52p ps=16.88u w=8u l=0.28u
X101 VSS.t3 a_15180_41600.t59 O_SENSE.t4 VSS.t2 nfet_03v3 ad=2.08p pd=8.52u as=2.08p ps=8.52u w=8u l=0.28u
X102 E_CAPTURE_CLK.t6 a_4812_6400.t16 VDD.t173 VDD.t172 pfet_03v3 ad=3.52p pd=16.88u as=2.08p ps=8.52u w=8u l=0.28u
X103 VSS.t73 CLKP_H.t1 a_4812_6400.t6 VSS.t72 nfet_03v3 ad=2.08p pd=8.52u as=2.08p ps=8.52u w=8u l=0.28u
X104 a_4812_6400.t1 CLKP_H.t6 VDD.t57 VDD.t56 pfet_03v3 ad=2.08p pd=8.52u as=2.08p ps=8.52u w=8u l=0.28u
X105 a_15180_6400.t20 a_6924_6400.t40 VDD.t145 VDD.t144 pfet_03v3 ad=3.52p pd=16.88u as=2.08p ps=8.52u w=8u l=0.28u
X106 a_2700_41600.t1 CLKN_HB.t22 VDD.t107 VDD.t106 pfet_03v3 ad=2.08p pd=8.52u as=2.08p ps=8.52u w=8u l=0.28u
X107 VDD.t217 a_6924_41600.t57 a_15180_41600.t29 VDD.t216 pfet_03v3 ad=2.08p pd=8.52u as=2.08p ps=8.52u w=8u l=0.28u
X108 VDD.t343 a_15180_41600.t111 O_SENSE.t59 VDD.t342 pfet_03v3 ad=2.08p pd=8.52u as=3.52p ps=16.88u w=8u l=0.28u
X109 VSS.t193 a_15180_6400.t67 E_SENSE.t40 VSS.t192 nfet_03v3 ad=2.08p pd=8.52u as=2.08p ps=8.52u w=8u l=0.28u
X110 VSS.t349 a_2700_6400.t13 E_CAPTURE_CLKB.t12 VSS.t348 nfet_03v3 ad=2.08p pd=8.52u as=2.08p ps=8.52u w=8u l=0.28u
X111 E_SENSE.t49 a_15180_6400.t100 VDD.t183 VDD.t182 pfet_03v3 ad=2.08p pd=8.52u as=2.08p ps=8.52u w=8u l=0.28u
X112 O_SENSE.t62 a_15180_41600.t78 VSS.t345 VSS.t344 nfet_03v3 ad=2.08p pd=8.52u as=2.08p ps=8.52u w=8u l=0.28u
X113 a_15180_6400.t11 a_6924_6400.t36 VSS.t95 VSS.t94 nfet_03v3 ad=2.08p pd=8.52u as=2.08p ps=8.52u w=8u l=0.28u
X114 VDD.t247 a_4812_41600.t19 O_CAPTURE_CLK.t9 VDD.t246 pfet_03v3 ad=2.08p pd=8.52u as=2.08p ps=8.52u w=8u l=0.28u
X115 a_15180_41600.t18 a_6924_41600.t54 VDD.t133 VDD.t132 pfet_03v3 ad=2.08p pd=8.52u as=2.08p ps=8.52u w=8u l=0.28u
X116 VSS.t119 a_6924_41600.t19 a_15180_41600.t14 VSS.t118 nfet_03v3 ad=2.08p pd=8.52u as=2.08p ps=8.52u w=8u l=0.28u
X117 VSS.t197 a_15180_6400.t59 E_SENSE.t42 VSS.t196 nfet_03v3 ad=2.08p pd=8.52u as=2.08p ps=8.52u w=8u l=0.28u
X118 VDD.t151 a_6924_6400.t61 a_15180_6400.t25 VDD.t150 pfet_03v3 ad=2.08p pd=8.52u as=2.08p ps=8.52u w=8u l=0.28u
X119 a_15180_6400.t18 a_6924_6400.t34 VSS.t179 VSS.t178 nfet_03v3 ad=2.08p pd=8.52u as=2.08p ps=8.52u w=8u l=0.28u
X120 a_6924_6400.t9 CLKP_HB.t6 VSS.t307 VSS.t306 nfet_03v3 ad=2.08p pd=8.52u as=2.08p ps=8.52u w=8u l=0.28u
X121 VDD.t333 a_6924_41600.t41 a_15180_41600.t44 VDD.t332 pfet_03v3 ad=2.08p pd=8.52u as=2.08p ps=8.52u w=8u l=0.28u
X122 O_CAPTURE_CLK.t10 a_4812_41600.t10 VSS.t267 VSS.t266 nfet_03v3 ad=2.08p pd=8.52u as=2.08p ps=8.52u w=8u l=0.28u
X123 VDD.t19 a_6924_41600.t63 a_15180_41600.t0 VDD.t18 pfet_03v3 ad=2.08p pd=8.52u as=3.52p ps=16.88u w=8u l=0.28u
X124 VDD.t25 a_2700_41600.t21 O_CAPTURE_CLKB.t1 VDD.t24 pfet_03v3 ad=2.08p pd=8.52u as=2.08p ps=8.52u w=8u l=0.28u
X125 O_CAPTURE_CLK.t14 a_4812_41600.t16 VDD.t337 VDD.t336 pfet_03v3 ad=3.52p pd=16.88u as=2.08p ps=8.52u w=8u l=0.28u
X126 O_SENSE.t54 a_15180_41600.t94 VDD.t325 VDD.t324 pfet_03v3 ad=2.08p pd=8.52u as=2.08p ps=8.52u w=8u l=0.28u
X127 a_15180_41600.t27 a_6924_41600.t16 VSS.t229 VSS.t228 nfet_03v3 ad=3.52p pd=16.88u as=2.08p ps=8.52u w=8u l=0.28u
X128 VSS.t221 a_15180_41600.t51 O_SENSE.t31 VSS.t220 nfet_03v3 ad=2.08p pd=8.52u as=2.08p ps=8.52u w=8u l=0.28u
X129 E_CAPTURE_CLKB.t3 a_2700_6400.t8 VSS.t123 VSS.t122 nfet_03v3 ad=3.52p pd=16.88u as=2.08p ps=8.52u w=8u l=0.28u
X130 VDD.t141 a_15180_41600.t81 O_SENSE.t21 VDD.t140 pfet_03v3 ad=2.08p pd=8.52u as=2.08p ps=8.52u w=8u l=0.28u
X131 a_15180_41600.t34 a_6924_41600.t38 VSS.t249 VSS.t248 nfet_03v3 ad=2.08p pd=8.52u as=2.08p ps=8.52u w=8u l=0.28u
X132 E_SENSE.t43 a_15180_6400.t60 VSS.t199 VSS.t198 nfet_03v3 ad=2.08p pd=8.52u as=2.08p ps=8.52u w=8u l=0.28u
X133 O_CAPTURE_CLKB.t11 a_2700_41600.t12 VSS.t97 VSS.t96 nfet_03v3 ad=2.08p pd=8.52u as=2.08p ps=8.52u w=8u l=0.28u
X134 a_15180_6400.t26 a_6924_6400.t62 VDD.t153 VDD.t152 pfet_03v3 ad=2.08p pd=8.52u as=2.08p ps=8.52u w=8u l=0.28u
X135 VSS.t305 CLKP_HB.t7 a_6924_6400.t8 VSS.t304 nfet_03v3 ad=2.08p pd=8.52u as=3.52p ps=16.88u w=8u l=0.28u
X136 a_15180_41600.t6 a_6924_41600.t60 VDD.t63 VDD.t62 pfet_03v3 ad=2.08p pd=8.52u as=2.08p ps=8.52u w=8u l=0.28u
X137 VDD.t161 a_15180_6400.t93 E_SENSE.t34 VDD.t160 pfet_03v3 ad=2.08p pd=8.52u as=2.08p ps=8.52u w=8u l=0.28u
X138 O_CAPTURE_CLKB.t14 a_2700_41600.t18 VDD.t203 VDD.t202 pfet_03v3 ad=2.08p pd=8.52u as=2.08p ps=8.52u w=8u l=0.28u
X139 O_SENSE.t58 a_15180_41600.t48 VSS.t331 VSS.t330 nfet_03v3 ad=3.52p pd=16.88u as=2.08p ps=8.52u w=8u l=0.28u
X140 VSS.t77 a_6924_6400.t29 a_15180_6400.t8 VSS.t76 nfet_03v3 ad=2.08p pd=8.52u as=2.08p ps=8.52u w=8u l=0.28u
X141 VSS.t315 CLKP_HB.t1 a_6924_6400.t14 VSS.t314 nfet_03v3 ad=2.08p pd=8.52u as=2.08p ps=8.52u w=8u l=0.28u
X142 VSS.t263 a_6924_41600.t35 a_15180_41600.t37 VSS.t262 nfet_03v3 ad=2.08p pd=8.52u as=2.08p ps=8.52u w=8u l=0.28u
X143 O_SENSE.t29 a_15180_41600.t70 VSS.t207 VSS.t206 nfet_03v3 ad=2.08p pd=8.52u as=2.08p ps=8.52u w=8u l=0.28u
X144 VSS.t169 a_6924_6400.t27 a_15180_6400.t13 VSS.t168 nfet_03v3 ad=2.08p pd=8.52u as=2.08p ps=8.52u w=8u l=0.28u
X145 VSS.t85 a_2700_6400.t9 E_CAPTURE_CLKB.t1 VSS.t84 nfet_03v3 ad=2.08p pd=8.52u as=2.08p ps=8.52u w=8u l=0.28u
X146 O_CAPTURE_CLK.t0 a_4812_41600.t22 VDD.t221 VDD.t220 pfet_03v3 ad=2.08p pd=8.52u as=2.08p ps=8.52u w=8u l=0.28u
X147 VSS.t101 a_2700_41600.t9 O_CAPTURE_CLKB.t13 VSS.t100 nfet_03v3 ad=2.08p pd=8.52u as=2.08p ps=8.52u w=8u l=0.28u
X148 E_CAPTURE_CLKB.t13 a_2700_6400.t18 VDD.t347 VDD.t346 pfet_03v3 ad=2.08p pd=8.52u as=2.08p ps=8.52u w=8u l=0.28u
X149 O_SENSE.t14 a_15180_41600.t100 VDD.t71 VDD.t70 pfet_03v3 ad=2.08p pd=8.52u as=2.08p ps=8.52u w=8u l=0.28u
X150 a_15180_41600.t22 a_6924_41600.t22 VSS.t155 VSS.t154 nfet_03v3 ad=2.08p pd=8.52u as=2.08p ps=8.52u w=8u l=0.28u
X151 a_2700_41600.t3 CLKN_HB.t20 VDD.t113 VDD.t112 pfet_03v3 ad=3.52p pd=16.88u as=2.08p ps=8.52u w=8u l=0.28u
X152 a_4812_41600.t7 CLKN_H.t0 VSS.t11 VSS.t10 nfet_03v3 ad=3.52p pd=16.88u as=2.08p ps=8.52u w=8u l=0.28u
X153 E_SENSE.t35 a_15180_6400.t94 VDD.t163 VDD.t162 pfet_03v3 ad=2.08p pd=8.52u as=2.08p ps=8.52u w=8u l=0.28u
X154 VSS.t253 a_4812_41600.t13 O_CAPTURE_CLK.t7 VSS.t252 nfet_03v3 ad=2.08p pd=8.52u as=2.08p ps=8.52u w=8u l=0.28u
X155 VSS.t61 a_15180_41600.t67 O_SENSE.t10 VSS.t60 nfet_03v3 ad=2.08p pd=8.52u as=2.08p ps=8.52u w=8u l=0.28u
X156 a_15180_6400.t9 a_6924_6400.t30 VSS.t79 VSS.t78 nfet_03v3 ad=2.08p pd=8.52u as=2.08p ps=8.52u w=8u l=0.28u
X157 a_6924_6400.t13 CLKP_HB.t2 VSS.t313 VSS.t312 nfet_03v3 ad=2.08p pd=8.52u as=2.08p ps=8.52u w=8u l=0.28u
X158 O_SENSE.t57 a_15180_41600.t54 VSS.t329 VSS.t328 nfet_03v3 ad=2.08p pd=8.52u as=2.08p ps=8.52u w=8u l=0.28u
X159 VDD.t297 CLKP_HB.t15 a_6924_6400.t4 VDD.t296 pfet_03v3 ad=2.08p pd=8.52u as=2.08p ps=8.52u w=8u l=0.28u
X160 VDD.t47 a_6924_6400.t55 a_15180_6400.t4 VDD.t46 pfet_03v3 ad=2.08p pd=8.52u as=2.08p ps=8.52u w=8u l=0.28u
X161 VSS.t51 a_15180_6400.t53 E_SENSE.t12 VSS.t50 nfet_03v3 ad=2.08p pd=8.52u as=2.08p ps=8.52u w=8u l=0.28u
X162 a_15180_6400.t14 a_6924_6400.t28 VSS.t171 VSS.t170 nfet_03v3 ad=2.08p pd=8.52u as=2.08p ps=8.52u w=8u l=0.28u
X163 a_6924_6400.t15 CLKP_HB.t0 VSS.t317 VSS.t316 nfet_03v3 ad=3.52p pd=16.88u as=2.08p ps=8.52u w=8u l=0.28u
X164 VDD.t139 a_15180_41600.t97 O_SENSE.t20 VDD.t138 pfet_03v3 ad=2.08p pd=8.52u as=2.08p ps=8.52u w=8u l=0.28u
X165 a_6924_41600.t11 CLKN_HB.t4 VSS.t127 VSS.t126 nfet_03v3 ad=2.08p pd=8.52u as=2.08p ps=8.52u w=8u l=0.28u
X166 O_SENSE.t52 a_15180_41600.t76 VSS.t319 VSS.t318 nfet_03v3 ad=2.08p pd=8.52u as=2.08p ps=8.52u w=8u l=0.28u
X167 VDD.t259 a_2700_6400.t19 E_CAPTURE_CLKB.t8 VDD.t258 pfet_03v3 ad=2.08p pd=8.52u as=2.08p ps=8.52u w=8u l=0.28u
X168 VSS.t201 a_15180_6400.t51 E_SENSE.t44 VSS.t200 nfet_03v3 ad=2.08p pd=8.52u as=2.08p ps=8.52u w=8u l=0.28u
X169 E_SENSE.t5 a_15180_6400.t86 VDD.t37 VDD.t36 pfet_03v3 ad=2.08p pd=8.52u as=2.08p ps=8.52u w=8u l=0.28u
X170 E_CAPTURE_CLK.t15 a_4812_6400.t14 VSS.t351 VSS.t350 nfet_03v3 ad=2.08p pd=8.52u as=2.08p ps=8.52u w=8u l=0.28u
X171 a_15180_41600.t13 a_6924_41600.t52 VDD.t103 VDD.t102 pfet_03v3 ad=2.08p pd=8.52u as=2.08p ps=8.52u w=8u l=0.28u
X172 O_SENSE.t18 a_15180_41600.t106 VDD.t135 VDD.t134 pfet_03v3 ad=2.08p pd=8.52u as=2.08p ps=8.52u w=8u l=0.28u
X173 a_15180_6400.t22 a_6924_6400.t22 VSS.t187 VSS.t186 nfet_03v3 ad=2.08p pd=8.52u as=2.08p ps=8.52u w=8u l=0.28u
X174 VSS.t145 CLKN_HB.t1 a_6924_41600.t14 VSS.t144 nfet_03v3 ad=2.08p pd=8.52u as=2.08p ps=8.52u w=8u l=0.28u
X175 VSS.t205 a_15180_41600.t73 O_SENSE.t28 VSS.t204 nfet_03v3 ad=2.08p pd=8.52u as=2.08p ps=8.52u w=8u l=0.28u
X176 E_SENSE.t55 a_15180_6400.t74 VSS.t211 VSS.t210 nfet_03v3 ad=2.08p pd=8.52u as=2.08p ps=8.52u w=8u l=0.28u
X177 VSS.t239 a_2700_6400.t15 E_CAPTURE_CLKB.t5 VSS.t238 nfet_03v3 ad=2.08p pd=8.52u as=3.52p ps=16.88u w=8u l=0.28u
X178 VDD.t91 a_15180_6400.t87 E_SENSE.t20 VDD.t90 pfet_03v3 ad=2.08p pd=8.52u as=2.08p ps=8.52u w=8u l=0.28u
X179 VDD.t65 a_6924_41600.t49 a_15180_41600.t7 VDD.t64 pfet_03v3 ad=2.08p pd=8.52u as=2.08p ps=8.52u w=8u l=0.28u
X180 VDD.t41 a_15180_41600.t103 O_SENSE.t6 VDD.t40 pfet_03v3 ad=2.08p pd=8.52u as=2.08p ps=8.52u w=8u l=0.28u
X181 VSS.t333 a_6924_6400.t23 a_15180_6400.t46 VSS.t332 nfet_03v3 ad=2.08p pd=8.52u as=2.08p ps=8.52u w=8u l=0.28u
X182 VSS.t67 a_4812_6400.t15 E_CAPTURE_CLK.t2 VSS.t66 nfet_03v3 ad=2.08p pd=8.52u as=3.52p ps=16.88u w=8u l=0.28u
X183 VSS.t295 CLKP_HB.t11 a_2700_6400.t4 VSS.t294 nfet_03v3 ad=2.08p pd=8.52u as=3.52p ps=16.88u w=8u l=0.28u
X184 VDD.t105 CLKN_HB.t23 a_2700_41600.t0 VDD.t104 pfet_03v3 ad=2.08p pd=8.52u as=3.52p ps=16.88u w=8u l=0.28u
X185 a_15180_41600.t43 a_6924_41600.t58 VDD.t331 VDD.t330 pfet_03v3 ad=2.08p pd=8.52u as=2.08p ps=8.52u w=8u l=0.28u
X186 a_15180_6400.t40 a_6924_6400.t48 VDD.t291 VDD.t290 pfet_03v3 ad=2.08p pd=8.52u as=2.08p ps=8.52u w=8u l=0.28u
X187 VSS.t185 a_6924_6400.t21 a_15180_6400.t21 VSS.t184 nfet_03v3 ad=2.08p pd=8.52u as=2.08p ps=8.52u w=8u l=0.28u
X188 VDD.t345 a_15180_41600.t89 O_SENSE.t61 VDD.t344 pfet_03v3 ad=2.08p pd=8.52u as=2.08p ps=8.52u w=8u l=0.28u
X189 VSS.t37 a_15180_6400.t77 E_SENSE.t6 VSS.t36 nfet_03v3 ad=2.08p pd=8.52u as=2.08p ps=8.52u w=8u l=0.28u
X190 VDD.t115 CLKN_HB.t19 a_6924_41600.t0 VDD.t114 pfet_03v3 ad=2.08p pd=8.52u as=3.52p ps=16.88u w=8u l=0.28u
X191 a_2700_41600.t5 CLKN_HB.t10 VSS.t129 VSS.t128 nfet_03v3 ad=2.08p pd=8.52u as=2.08p ps=8.52u w=8u l=0.28u
X192 E_SENSE.t47 a_15180_6400.t110 VDD.t179 VDD.t178 pfet_03v3 ad=2.08p pd=8.52u as=2.08p ps=8.52u w=8u l=0.28u
X193 VSS.t189 a_15180_6400.t75 E_SENSE.t38 VSS.t188 nfet_03v3 ad=2.08p pd=8.52u as=2.08p ps=8.52u w=8u l=0.28u
X194 VSS.t321 a_6924_41600.t33 a_15180_41600.t41 VSS.t320 nfet_03v3 ad=2.08p pd=8.52u as=2.08p ps=8.52u w=8u l=0.28u
X195 VSS.t225 a_15180_41600.t79 O_SENSE.t32 VSS.t224 nfet_03v3 ad=2.08p pd=8.52u as=3.52p ps=16.88u w=8u l=0.28u
X196 E_SENSE.t17 a_15180_6400.t108 VDD.t85 VDD.t84 pfet_03v3 ad=2.08p pd=8.52u as=2.08p ps=8.52u w=8u l=0.28u
X197 VDD.t229 a_6924_41600.t55 a_15180_41600.t32 VDD.t228 pfet_03v3 ad=2.08p pd=8.52u as=2.08p ps=8.52u w=8u l=0.28u
X198 VDD.t255 a_6924_6400.t49 a_15180_6400.t29 VDD.t254 pfet_03v3 ad=2.08p pd=8.52u as=2.08p ps=8.52u w=8u l=0.28u
X199 VSS.t269 a_4812_41600.t11 O_CAPTURE_CLK.t11 VSS.t268 nfet_03v3 ad=2.08p pd=8.52u as=2.08p ps=8.52u w=8u l=0.28u
X200 E_CAPTURE_CLK.t0 a_4812_6400.t8 VSS.t25 VSS.t24 nfet_03v3 ad=3.52p pd=16.88u as=2.08p ps=8.52u w=8u l=0.28u
X201 E_SENSE.t23 a_15180_6400.t80 VDD.t95 VDD.t94 pfet_03v3 ad=3.52p pd=16.88u as=2.08p ps=8.52u w=8u l=0.28u
X202 a_15180_41600.t20 a_6924_41600.t30 VSS.t151 VSS.t150 nfet_03v3 ad=2.08p pd=8.52u as=2.08p ps=8.52u w=8u l=0.28u
X203 a_15180_6400.t12 a_6924_6400.t16 VSS.t157 VSS.t156 nfet_03v3 ad=3.52p pd=16.88u as=2.08p ps=8.52u w=8u l=0.28u
X204 VDD.t339 a_4812_41600.t17 O_CAPTURE_CLK.t15 VDD.t338 pfet_03v3 ad=2.08p pd=8.52u as=2.08p ps=8.52u w=8u l=0.28u
X205 VDD.t209 a_15180_41600.t95 O_SENSE.t35 VDD.t208 pfet_03v3 ad=2.08p pd=8.52u as=2.08p ps=8.52u w=8u l=0.28u
X206 VSS.t81 a_6924_41600.t17 a_15180_41600.t9 VSS.t80 nfet_03v3 ad=2.08p pd=8.52u as=2.08p ps=8.52u w=8u l=0.28u
X207 VDD.t341 a_4812_6400.t17 E_CAPTURE_CLK.t14 VDD.t340 pfet_03v3 ad=2.08p pd=8.52u as=2.08p ps=8.52u w=8u l=0.28u
X208 a_4812_6400.t5 CLKP_H.t2 VSS.t71 VSS.t70 nfet_03v3 ad=2.08p pd=8.52u as=2.08p ps=8.52u w=8u l=0.28u
X209 VSS.t237 a_6924_41600.t39 a_15180_41600.t30 VSS.t236 nfet_03v3 ad=2.08p pd=8.52u as=3.52p ps=16.88u w=8u l=0.28u
X210 VDD.t51 a_6924_6400.t41 a_15180_6400.t6 VDD.t50 pfet_03v3 ad=2.08p pd=8.52u as=2.08p ps=8.52u w=8u l=0.28u
X211 VSS.t99 a_2700_41600.t13 O_CAPTURE_CLKB.t12 VSS.t98 nfet_03v3 ad=2.08p pd=8.52u as=2.08p ps=8.52u w=8u l=0.28u
X212 O_CAPTURE_CLK.t12 a_4812_41600.t8 VSS.t271 VSS.t270 nfet_03v3 ad=3.52p pd=16.88u as=2.08p ps=8.52u w=8u l=0.28u
X213 O_SENSE.t24 a_15180_41600.t62 VSS.t165 VSS.t164 nfet_03v3 ad=2.08p pd=8.52u as=2.08p ps=8.52u w=8u l=0.28u
X214 VDD.t99 a_6924_41600.t61 a_15180_41600.t11 VDD.t98 pfet_03v3 ad=2.08p pd=8.52u as=2.08p ps=8.52u w=8u l=0.28u
X215 VDD.t157 a_15180_6400.t103 E_SENSE.t32 VDD.t156 pfet_03v3 ad=2.08p pd=8.52u as=2.08p ps=8.52u w=8u l=0.28u
X216 E_SENSE.t41 a_15180_6400.t68 VSS.t195 VSS.t194 nfet_03v3 ad=2.08p pd=8.52u as=2.08p ps=8.52u w=8u l=0.28u
X217 O_SENSE.t40 a_15180_41600.t92 VDD.t225 VDD.t224 pfet_03v3 ad=2.08p pd=8.52u as=2.08p ps=8.52u w=8u l=0.28u
X218 VSS.t261 a_15180_41600.t49 O_SENSE.t45 VSS.t260 nfet_03v3 ad=2.08p pd=8.52u as=2.08p ps=8.52u w=8u l=0.28u
X219 VDD.t265 a_15180_6400.t101 E_SENSE.t60 VDD.t264 pfet_03v3 ad=2.08p pd=8.52u as=2.08p ps=8.52u w=8u l=0.28u
X220 a_15180_41600.t38 a_6924_41600.t36 VSS.t265 VSS.t264 nfet_03v3 ad=2.08p pd=8.52u as=2.08p ps=8.52u w=8u l=0.28u
X221 E_CAPTURE_CLK.t3 a_4812_6400.t18 VDD.t97 VDD.t96 pfet_03v3 ad=2.08p pd=8.52u as=2.08p ps=8.52u w=8u l=0.28u
X222 a_15180_6400.t7 a_6924_6400.t42 VDD.t53 VDD.t52 pfet_03v3 ad=2.08p pd=8.52u as=2.08p ps=8.52u w=8u l=0.28u
X223 VSS.t173 a_6924_6400.t37 a_15180_6400.t15 VSS.t172 nfet_03v3 ad=2.08p pd=8.52u as=2.08p ps=8.52u w=8u l=0.28u
X224 VDD.t11 CLKN_H.t7 a_4812_41600.t0 VDD.t10 pfet_03v3 ad=2.08p pd=8.52u as=3.52p ps=16.88u w=8u l=0.28u
X225 VDD.t249 a_15180_41600.t101 O_SENSE.t46 VDD.t248 pfet_03v3 ad=2.08p pd=8.52u as=2.08p ps=8.52u w=8u l=0.28u
X226 O_CAPTURE_CLKB.t4 a_2700_41600.t10 VSS.t33 VSS.t32 nfet_03v3 ad=2.08p pd=8.52u as=2.08p ps=8.52u w=8u l=0.28u
X227 O_CAPTURE_CLKB.t9 a_2700_41600.t16 VDD.t79 VDD.t78 pfet_03v3 ad=3.52p pd=16.88u as=2.08p ps=8.52u w=8u l=0.28u
X228 E_SENSE.t33 a_15180_6400.t104 VDD.t159 VDD.t158 pfet_03v3 ad=2.08p pd=8.52u as=2.08p ps=8.52u w=8u l=0.28u
X229 O_CAPTURE_CLK.t2 a_4812_41600.t14 VSS.t241 VSS.t240 nfet_03v3 ad=2.08p pd=8.52u as=2.08p ps=8.52u w=8u l=0.28u
X230 O_SENSE.t47 a_15180_41600.t68 VSS.t275 VSS.t274 nfet_03v3 ad=2.08p pd=8.52u as=2.08p ps=8.52u w=8u l=0.28u
X231 E_SENSE.t61 a_15180_6400.t102 VDD.t267 VDD.t266 pfet_03v3 ad=2.08p pd=8.52u as=2.08p ps=8.52u w=8u l=0.28u
X232 O_CAPTURE_CLK.t4 a_4812_41600.t20 VDD.t235 VDD.t234 pfet_03v3 ad=2.08p pd=8.52u as=2.08p ps=8.52u w=8u l=0.28u
X233 a_15180_41600.t26 a_6924_41600.t44 VDD.t201 VDD.t200 pfet_03v3 ad=2.08p pd=8.52u as=2.08p ps=8.52u w=8u l=0.28u
X234 O_SENSE.t7 a_15180_41600.t98 VDD.t43 VDD.t42 pfet_03v3 ad=2.08p pd=8.52u as=2.08p ps=8.52u w=8u l=0.28u
X235 a_2700_41600.t7 CLKN_HB.t8 VSS.t135 VSS.t134 nfet_03v3 ad=3.52p pd=16.88u as=2.08p ps=8.52u w=8u l=0.28u
X236 a_15180_6400.t16 a_6924_6400.t38 VSS.t175 VSS.t174 nfet_03v3 ad=2.08p pd=8.52u as=2.08p ps=8.52u w=8u l=0.28u
X237 E_SENSE.t3 a_15180_6400.t96 VDD.t33 VDD.t32 pfet_03v3 ad=2.08p pd=8.52u as=2.08p ps=8.52u w=8u l=0.28u
X238 VSS.t47 a_15180_6400.t61 E_SENSE.t10 VSS.t46 nfet_03v3 ad=2.08p pd=8.52u as=2.08p ps=8.52u w=8u l=0.28u
X239 VDD.t321 a_6924_6400.t63 a_15180_6400.t45 VDD.t320 pfet_03v3 ad=2.08p pd=8.52u as=3.52p ps=16.88u w=8u l=0.28u
X240 VSS.t89 a_15180_41600.t65 O_SENSE.t16 VSS.t88 nfet_03v3 ad=2.08p pd=8.52u as=2.08p ps=8.52u w=8u l=0.28u
X241 a_15180_41600.t47 a_6924_41600.t28 VSS.t339 VSS.t338 nfet_03v3 ad=2.08p pd=8.52u as=2.08p ps=8.52u w=8u l=0.28u
X242 O_SENSE.t22 a_15180_41600.t74 VSS.t161 VSS.t160 nfet_03v3 ad=2.08p pd=8.52u as=2.08p ps=8.52u w=8u l=0.28u
X243 E_CAPTURE_CLKB.t4 a_2700_6400.t10 VSS.t223 VSS.t222 nfet_03v3 ad=2.08p pd=8.52u as=2.08p ps=8.52u w=8u l=0.28u
X244 VDD.t87 a_15180_6400.t97 E_SENSE.t18 VDD.t86 pfet_03v3 ad=2.08p pd=8.52u as=2.08p ps=8.52u w=8u l=0.28u
X245 E_SENSE.t11 a_15180_6400.t62 VSS.t49 VSS.t48 nfet_03v3 ad=2.08p pd=8.52u as=2.08p ps=8.52u w=8u l=0.28u
X246 a_15180_41600.t8 a_6924_41600.t50 VDD.t67 VDD.t66 pfet_03v3 ad=2.08p pd=8.52u as=2.08p ps=8.52u w=8u l=0.28u
X247 VDD.t31 a_15180_6400.t95 E_SENSE.t2 VDD.t30 pfet_03v3 ad=2.08p pd=8.52u as=2.08p ps=8.52u w=8u l=0.28u
X248 VSS.t285 a_6924_41600.t25 a_15180_41600.t39 VSS.t284 nfet_03v3 ad=2.08p pd=8.52u as=2.08p ps=8.52u w=8u l=0.28u
X249 VSS.t327 a_15180_41600.t71 O_SENSE.t56 VSS.t326 nfet_03v3 ad=2.08p pd=8.52u as=2.08p ps=8.52u w=8u l=0.28u
X250 VSS.t13 a_6924_6400.t31 a_15180_6400.t2 VSS.t12 nfet_03v3 ad=2.08p pd=8.52u as=2.08p ps=8.52u w=8u l=0.28u
X251 VSS.t311 CLKP_HB.t3 a_6924_6400.t12 VSS.t310 nfet_03v3 ad=2.08p pd=8.52u as=2.08p ps=8.52u w=8u l=0.28u
X252 a_6924_6400.t3 CLKP_HB.t16 VDD.t307 VDD.t306 pfet_03v3 ad=2.08p pd=8.52u as=2.08p ps=8.52u w=8u l=0.28u
X253 a_15180_6400.t5 a_6924_6400.t56 VDD.t49 VDD.t48 pfet_03v3 ad=2.08p pd=8.52u as=2.08p ps=8.52u w=8u l=0.28u
X254 E_SENSE.t13 a_15180_6400.t54 VSS.t53 VSS.t52 nfet_03v3 ad=2.08p pd=8.52u as=2.08p ps=8.52u w=8u l=0.28u
X255 VSS.t109 a_2700_6400.t11 E_CAPTURE_CLKB.t2 VSS.t108 nfet_03v3 ad=2.08p pd=8.52u as=2.08p ps=8.52u w=8u l=0.28u
X256 VDD.t195 a_6924_41600.t47 a_15180_41600.t23 VDD.t194 pfet_03v3 ad=2.08p pd=8.52u as=2.08p ps=8.52u w=8u l=0.28u
X257 VSS.t131 CLKN_HB.t11 a_2700_41600.t4 VSS.t130 nfet_03v3 ad=2.08p pd=8.52u as=3.52p ps=16.88u w=8u l=0.28u
X258 a_15180_41600.t42 a_6924_41600.t34 VSS.t323 VSS.t322 nfet_03v3 ad=2.08p pd=8.52u as=2.08p ps=8.52u w=8u l=0.28u
X259 E_CAPTURE_CLKB.t10 a_2700_6400.t20 VDD.t263 VDD.t262 pfet_03v3 ad=2.08p pd=8.52u as=2.08p ps=8.52u w=8u l=0.28u
X260 VDD.t15 CLKN_H.t5 a_4812_41600.t2 VDD.t14 pfet_03v3 ad=2.08p pd=8.52u as=2.08p ps=8.52u w=8u l=0.28u
X261 a_15180_41600.t1 a_6924_41600.t56 VDD.t21 VDD.t20 pfet_03v3 ad=2.08p pd=8.52u as=2.08p ps=8.52u w=8u l=0.28u
X262 VSS.t167 a_15180_41600.t57 O_SENSE.t25 VSS.t166 nfet_03v3 ad=2.08p pd=8.52u as=2.08p ps=8.52u w=8u l=0.28u
X263 VDD.t327 a_15180_41600.t87 O_SENSE.t55 VDD.t326 pfet_03v3 ad=2.08p pd=8.52u as=2.08p ps=8.52u w=8u l=0.28u
X264 VSS.t125 CLKN_HB.t7 a_6924_41600.t8 VSS.t124 nfet_03v3 ad=2.08p pd=8.52u as=3.52p ps=16.88u w=8u l=0.28u
X265 VDD.t7 a_6924_6400.t59 a_15180_6400.t0 VDD.t6 pfet_03v3 ad=2.08p pd=8.52u as=2.08p ps=8.52u w=8u l=0.28u
X266 VDD.t119 CLKN_HB.t17 a_6924_41600.t2 VDD.t118 pfet_03v3 ad=2.08p pd=8.52u as=2.08p ps=8.52u w=8u l=0.28u
X267 VSS.t17 a_6924_41600.t31 a_15180_41600.t2 VSS.t16 nfet_03v3 ad=2.08p pd=8.52u as=2.08p ps=8.52u w=8u l=0.28u
X268 VDD.t313 CLKP_HB.t17 a_6924_6400.t2 VDD.t312 pfet_03v3 ad=2.08p pd=8.52u as=2.08p ps=8.52u w=8u l=0.28u
X269 VDD.t277 a_6924_6400.t57 a_15180_6400.t31 VDD.t276 pfet_03v3 ad=2.08p pd=8.52u as=2.08p ps=8.52u w=8u l=0.28u
X270 E_SENSE.t51 a_15180_6400.t90 VDD.t187 VDD.t186 pfet_03v3 ad=2.08p pd=8.52u as=2.08p ps=8.52u w=8u l=0.28u
X271 VSS.t115 a_15180_6400.t55 E_SENSE.t28 VSS.t114 nfet_03v3 ad=2.08p pd=8.52u as=2.08p ps=8.52u w=8u l=0.28u
X272 E_SENSE.t21 a_15180_6400.t88 VDD.t93 VDD.t92 pfet_03v3 ad=2.08p pd=8.52u as=2.08p ps=8.52u w=8u l=0.28u
X273 VDD.t131 a_6924_41600.t53 a_15180_41600.t17 VDD.t130 pfet_03v3 ad=2.08p pd=8.52u as=2.08p ps=8.52u w=8u l=0.28u
X274 a_15180_6400.t47 a_6924_6400.t24 VSS.t335 VSS.t334 nfet_03v3 ad=2.08p pd=8.52u as=2.08p ps=8.52u w=8u l=0.28u
X275 O_SENSE.t2 a_15180_41600.t84 VDD.t5 VDD.t4 pfet_03v3 ad=2.08p pd=8.52u as=2.08p ps=8.52u w=8u l=0.28u
X276 a_6924_41600.t5 CLKN_HB.t14 VDD.t123 VDD.t122 pfet_03v3 ad=2.08p pd=8.52u as=2.08p ps=8.52u w=8u l=0.28u
X277 VSS.t273 a_4812_41600.t9 O_CAPTURE_CLK.t13 VSS.t272 nfet_03v3 ad=2.08p pd=8.52u as=2.08p ps=8.52u w=8u l=0.28u
X278 VSS.t63 a_15180_41600.t63 O_SENSE.t11 VSS.t62 nfet_03v3 ad=2.08p pd=8.52u as=2.08p ps=8.52u w=8u l=0.28u
X279 E_SENSE.t7 a_15180_6400.t78 VSS.t39 VSS.t38 nfet_03v3 ad=2.08p pd=8.52u as=2.08p ps=8.52u w=8u l=0.28u
X280 VDD.t213 a_15180_41600.t93 O_SENSE.t37 VDD.t212 pfet_03v3 ad=2.08p pd=8.52u as=2.08p ps=8.52u w=8u l=0.28u
X281 VDD.t155 a_15180_6400.t111 E_SENSE.t31 VDD.t154 pfet_03v3 ad=2.08p pd=8.52u as=3.52p ps=16.88u w=8u l=0.28u
X282 VDD.t185 a_15180_6400.t89 E_SENSE.t50 VDD.t184 pfet_03v3 ad=2.08p pd=8.52u as=2.08p ps=8.52u w=8u l=0.28u
X283 E_SENSE.t39 a_15180_6400.t76 VSS.t191 VSS.t190 nfet_03v3 ad=2.08p pd=8.52u as=2.08p ps=8.52u w=8u l=0.28u
X284 O_CAPTURE_CLKB.t7 a_2700_41600.t22 VDD.t75 VDD.t74 pfet_03v3 ad=2.08p pd=8.52u as=2.08p ps=8.52u w=8u l=0.28u
X285 VSS.t247 a_6924_41600.t37 a_15180_41600.t33 VSS.t246 nfet_03v3 ad=2.08p pd=8.52u as=2.08p ps=8.52u w=8u l=0.28u
X286 VSS.t291 a_6924_6400.t25 a_15180_6400.t41 VSS.t290 nfet_03v3 ad=2.08p pd=8.52u as=2.08p ps=8.52u w=8u l=0.28u
X287 O_SENSE.t17 a_15180_41600.t60 VSS.t91 VSS.t90 nfet_03v3 ad=2.08p pd=8.52u as=2.08p ps=8.52u w=8u l=0.28u
X288 a_15180_6400.t30 a_6924_6400.t50 VDD.t257 VDD.t256 pfet_03v3 ad=2.08p pd=8.52u as=2.08p ps=8.52u w=8u l=0.28u
X289 E_SENSE.t30 a_15180_6400.t48 VSS.t159 VSS.t158 nfet_03v3 ad=3.52p pd=16.88u as=2.08p ps=8.52u w=8u l=0.28u
X290 O_SENSE.t30 a_15180_41600.t90 VDD.t193 VDD.t192 pfet_03v3 ad=2.08p pd=8.52u as=2.08p ps=8.52u w=8u l=0.28u
X291 VSS.t5 CLKN_H.t3 a_4812_41600.t4 VSS.t4 nfet_03v3 ad=2.08p pd=8.52u as=3.52p ps=16.88u w=8u l=0.28u
X292 E_CAPTURE_CLK.t13 a_4812_6400.t20 VDD.t329 VDD.t328 pfet_03v3 ad=2.08p pd=8.52u as=2.08p ps=8.52u w=8u l=0.28u
X293 VSS.t325 a_4812_6400.t9 E_CAPTURE_CLK.t12 VSS.t324 nfet_03v3 ad=2.08p pd=8.52u as=2.08p ps=8.52u w=8u l=0.28u
X294 VDD.t189 a_15180_6400.t81 E_SENSE.t52 VDD.t188 pfet_03v3 ad=2.08p pd=8.52u as=2.08p ps=8.52u w=8u l=0.28u
X295 VSS.t279 a_15180_41600.t69 O_SENSE.t51 VSS.t278 nfet_03v3 ad=2.08p pd=8.52u as=2.08p ps=8.52u w=8u l=0.28u
X296 VSS.t255 a_6924_6400.t17 a_15180_6400.t27 VSS.t254 nfet_03v3 ad=2.08p pd=8.52u as=2.08p ps=8.52u w=8u l=0.28u
X297 VDD.t241 a_6924_41600.t45 a_15180_41600.t35 VDD.t240 pfet_03v3 ad=2.08p pd=8.52u as=2.08p ps=8.52u w=8u l=0.28u
X298 O_CAPTURE_CLKB.t6 a_2700_41600.t8 VSS.t87 VSS.t86 nfet_03v3 ad=3.52p pd=16.88u as=2.08p ps=8.52u w=8u l=0.28u
X299 VSS.t105 a_15180_6400.t71 E_SENSE.t24 VSS.t104 nfet_03v3 ad=2.08p pd=8.52u as=2.08p ps=8.52u w=8u l=0.28u
X300 E_SENSE.t37 a_15180_6400.t84 VDD.t167 VDD.t166 pfet_03v3 ad=2.08p pd=8.52u as=2.08p ps=8.52u w=8u l=0.28u
X301 O_CAPTURE_CLK.t6 a_4812_41600.t12 VSS.t251 VSS.t250 nfet_03v3 ad=2.08p pd=8.52u as=2.08p ps=8.52u w=8u l=0.28u
X302 a_15180_41600.t15 a_6924_41600.t20 VSS.t121 VSS.t120 nfet_03v3 ad=2.08p pd=8.52u as=2.08p ps=8.52u w=8u l=0.28u
X303 VDD.t273 a_15180_41600.t109 O_SENSE.t50 VDD.t272 pfet_03v3 ad=2.08p pd=8.52u as=2.08p ps=8.52u w=8u l=0.28u
X304 O_SENSE.t23 a_15180_41600.t66 VSS.t163 VSS.t162 nfet_03v3 ad=2.08p pd=8.52u as=2.08p ps=8.52u w=8u l=0.28u
X305 VDD.t251 a_4812_6400.t21 E_CAPTURE_CLK.t9 VDD.t250 pfet_03v3 ad=2.08p pd=8.52u as=2.08p ps=8.52u w=8u l=0.28u
X306 VSS.t41 a_15180_6400.t69 E_SENSE.t8 VSS.t40 nfet_03v3 ad=2.08p pd=8.52u as=2.08p ps=8.52u w=8u l=0.28u
X307 E_CAPTURE_CLK.t11 a_4812_6400.t10 VSS.t289 VSS.t288 nfet_03v3 ad=2.08p pd=8.52u as=2.08p ps=8.52u w=8u l=0.28u
X308 E_SENSE.t53 a_15180_6400.t82 VDD.t191 VDD.t190 pfet_03v3 ad=2.08p pd=8.52u as=2.08p ps=8.52u w=8u l=0.28u
X309 a_15180_41600.t45 a_6924_41600.t42 VDD.t335 VDD.t334 pfet_03v3 ad=2.08p pd=8.52u as=2.08p ps=8.52u w=8u l=0.28u
X310 O_SENSE.t33 a_15180_41600.t96 VDD.t207 VDD.t206 pfet_03v3 ad=2.08p pd=8.52u as=2.08p ps=8.52u w=8u l=0.28u
X311 a_15180_6400.t28 a_6924_6400.t18 VSS.t257 VSS.t256 nfet_03v3 ad=2.08p pd=8.52u as=2.08p ps=8.52u w=8u l=0.28u
X312 VDD.t175 a_4812_6400.t19 E_CAPTURE_CLK.t7 VDD.t174 pfet_03v3 ad=2.08p pd=8.52u as=2.08p ps=8.52u w=8u l=0.28u
X313 VDD.t293 a_6924_6400.t43 a_15180_6400.t43 VDD.t292 pfet_03v3 ad=2.08p pd=8.52u as=2.08p ps=8.52u w=8u l=0.28u
X314 E_SENSE.t25 a_15180_6400.t72 VSS.t107 VSS.t106 nfet_03v3 ad=2.08p pd=8.52u as=2.08p ps=8.52u w=8u l=0.28u
X315 VDD.t101 a_6924_41600.t51 a_15180_41600.t12 VDD.t100 pfet_03v3 ad=2.08p pd=8.52u as=2.08p ps=8.52u w=8u l=0.28u
X316 E_CAPTURE_CLKB.t6 a_2700_6400.t22 VDD.t231 VDD.t230 pfet_03v3 ad=2.08p pd=8.52u as=2.08p ps=8.52u w=8u l=0.28u
X317 O_SENSE.t8 a_15180_41600.t82 VDD.t45 VDD.t44 pfet_03v3 ad=2.08p pd=8.52u as=2.08p ps=8.52u w=8u l=0.28u
X318 VDD.t27 a_15180_6400.t105 E_SENSE.t0 VDD.t26 pfet_03v3 ad=2.08p pd=8.52u as=2.08p ps=8.52u w=8u l=0.28u
X319 E_SENSE.t9 a_15180_6400.t70 VSS.t43 VSS.t42 nfet_03v3 ad=2.08p pd=8.52u as=2.08p ps=8.52u w=8u l=0.28u
X320 a_6924_41600.t7 CLKN_HB.t12 VDD.t127 VDD.t126 pfet_03v3 ad=3.52p pd=16.88u as=2.08p ps=8.52u w=8u l=0.28u
X321 a_15180_41600.t40 a_6924_41600.t26 VSS.t287 VSS.t286 nfet_03v3 ad=2.08p pd=8.52u as=2.08p ps=8.52u w=8u l=0.28u
X322 a_2700_6400.t1 CLKP_HB.t22 VDD.t301 VDD.t300 pfet_03v3 ad=2.08p pd=8.52u as=2.08p ps=8.52u w=8u l=0.28u
X323 VDD.t205 a_2700_41600.t19 O_CAPTURE_CLKB.t15 VDD.t204 pfet_03v3 ad=2.08p pd=8.52u as=2.08p ps=8.52u w=8u l=0.28u
X324 a_2700_6400.t3 CLKP_HB.t20 VDD.t305 VDD.t304 pfet_03v3 ad=3.52p pd=16.88u as=2.08p ps=8.52u w=8u l=0.28u
X325 a_15180_6400.t44 a_6924_6400.t44 VDD.t295 VDD.t294 pfet_03v3 ad=2.08p pd=8.52u as=2.08p ps=8.52u w=8u l=0.28u
X326 E_SENSE.t27 a_15180_6400.t64 VSS.t113 VSS.t112 nfet_03v3 ad=2.08p pd=8.52u as=2.08p ps=8.52u w=8u l=0.28u
X327 VSS.t183 a_6924_6400.t39 a_15180_6400.t19 VSS.t182 nfet_03v3 ad=2.08p pd=8.52u as=3.52p ps=16.88u w=8u l=0.28u
X328 a_15180_41600.t24 a_6924_41600.t48 VDD.t197 VDD.t196 pfet_03v3 ad=2.08p pd=8.52u as=2.08p ps=8.52u w=8u l=0.28u
X329 a_4812_41600.t1 CLKN_H.t6 VDD.t13 VDD.t12 pfet_03v3 ad=2.08p pd=8.52u as=2.08p ps=8.52u w=8u l=0.28u
X330 VDD.t223 a_4812_41600.t23 O_CAPTURE_CLK.t1 VDD.t222 pfet_03v3 ad=2.08p pd=8.52u as=3.52p ps=16.88u w=8u l=0.28u
X331 VSS.t21 a_6924_41600.t23 a_15180_41600.t4 VSS.t20 nfet_03v3 ad=2.08p pd=8.52u as=2.08p ps=8.52u w=8u l=0.28u
X332 a_4812_6400.t3 CLKP_H.t4 VDD.t61 VDD.t60 pfet_03v3 ad=3.52p pd=16.88u as=2.08p ps=8.52u w=8u l=0.28u
X333 O_SENSE.t43 a_15180_41600.t88 VDD.t239 VDD.t238 pfet_03v3 ad=2.08p pd=8.52u as=2.08p ps=8.52u w=8u l=0.28u
X334 VSS.t9 CLKN_H.t1 a_4812_41600.t6 VSS.t8 nfet_03v3 ad=2.08p pd=8.52u as=2.08p ps=8.52u w=8u l=0.28u
X335 VDD.t109 CLKN_HB.t21 a_2700_41600.t2 VDD.t108 pfet_03v3 ad=2.08p pd=8.52u as=2.08p ps=8.52u w=8u l=0.28u
X336 a_6924_41600.t1 CLKN_HB.t18 VDD.t117 VDD.t116 pfet_03v3 ad=2.08p pd=8.52u as=2.08p ps=8.52u w=8u l=0.28u
X337 a_15180_41600.t3 a_6924_41600.t32 VSS.t19 VSS.t18 nfet_03v3 ad=2.08p pd=8.52u as=2.08p ps=8.52u w=8u l=0.28u
X338 VDD.t303 CLKP_HB.t21 a_2700_6400.t2 VDD.t302 pfet_03v3 ad=2.08p pd=8.52u as=2.08p ps=8.52u w=8u l=0.28u
X339 VSS.t213 a_15180_6400.t65 E_SENSE.t56 VSS.t212 nfet_03v3 ad=2.08p pd=8.52u as=2.08p ps=8.52u w=8u l=0.28u
X340 VSS.t233 a_15180_41600.t55 O_SENSE.t36 VSS.t232 nfet_03v3 ad=2.08p pd=8.52u as=2.08p ps=8.52u w=8u l=0.28u
X341 E_SENSE.t19 a_15180_6400.t98 VDD.t89 VDD.t88 pfet_03v3 ad=2.08p pd=8.52u as=2.08p ps=8.52u w=8u l=0.28u
X342 VSS.t111 a_15180_6400.t63 E_SENSE.t26 VSS.t110 nfet_03v3 ad=2.08p pd=8.52u as=2.08p ps=8.52u w=8u l=0.28u
X343 VSS.t139 CLKN_HB.t5 a_6924_41600.t10 VSS.t138 nfet_03v3 ad=2.08p pd=8.52u as=2.08p ps=8.52u w=8u l=0.28u
X344 VDD.t55 CLKP_H.t7 a_4812_6400.t0 VDD.t54 pfet_03v3 ad=2.08p pd=8.52u as=3.52p ps=16.88u w=8u l=0.28u
X345 VDD.t73 a_15180_41600.t85 O_SENSE.t15 VDD.t72 pfet_03v3 ad=2.08p pd=8.52u as=2.08p ps=8.52u w=8u l=0.28u
X346 VDD.t59 CLKP_H.t5 a_4812_6400.t2 VDD.t58 pfet_03v3 ad=2.08p pd=8.52u as=2.08p ps=8.52u w=8u l=0.28u
X347 VDD.t111 CLKN_HB.t15 a_6924_41600.t4 VDD.t110 pfet_03v3 ad=2.08p pd=8.52u as=2.08p ps=8.52u w=8u l=0.28u
X348 VDD.t39 a_15180_41600.t107 O_SENSE.t5 VDD.t38 pfet_03v3 ad=2.08p pd=8.52u as=2.08p ps=8.52u w=8u l=0.28u
X349 VSS.t149 a_6924_41600.t29 a_15180_41600.t19 VSS.t148 nfet_03v3 ad=2.08p pd=8.52u as=2.08p ps=8.52u w=8u l=0.28u
X350 a_15180_6400.t3 a_6924_6400.t32 VSS.t15 VSS.t14 nfet_03v3 ad=2.08p pd=8.52u as=2.08p ps=8.52u w=8u l=0.28u
X351 a_6924_6400.t11 CLKP_HB.t4 VSS.t297 VSS.t296 nfet_03v3 ad=2.08p pd=8.52u as=2.08p ps=8.52u w=8u l=0.28u
R0 E_SENSE E_SENSE.n62 11.7381
R1 E_SENSE.n62 E_SENSE.n30 6.5392
R2 E_SENSE.n32 E_SENSE.t30 5.7796
R3 E_SENSE.n1 E_SENSE.t23 5.73764
R4 E_SENSE.n61 E_SENSE.t22 5.59012
R5 E_SENSE.n30 E_SENSE.t31 5.54817
R6 E_SENSE.n32 E_SENSE.n31 5.38537
R7 E_SENSE.n34 E_SENSE.n33 5.38537
R8 E_SENSE.n36 E_SENSE.n35 5.38537
R9 E_SENSE.n38 E_SENSE.n37 5.38537
R10 E_SENSE.n40 E_SENSE.n39 5.38537
R11 E_SENSE.n42 E_SENSE.n41 5.38537
R12 E_SENSE.n44 E_SENSE.n43 5.38537
R13 E_SENSE.n46 E_SENSE.n45 5.38537
R14 E_SENSE.n48 E_SENSE.n47 5.38537
R15 E_SENSE.n50 E_SENSE.n49 5.38537
R16 E_SENSE.n52 E_SENSE.n51 5.38537
R17 E_SENSE.n54 E_SENSE.n53 5.38537
R18 E_SENSE.n56 E_SENSE.n55 5.38537
R19 E_SENSE.n58 E_SENSE.n57 5.38537
R20 E_SENSE.n60 E_SENSE.n59 5.38537
R21 E_SENSE.n1 E_SENSE.n0 5.32067
R22 E_SENSE.n3 E_SENSE.n2 5.32067
R23 E_SENSE.n5 E_SENSE.n4 5.32067
R24 E_SENSE.n7 E_SENSE.n6 5.32067
R25 E_SENSE.n9 E_SENSE.n8 5.32067
R26 E_SENSE.n11 E_SENSE.n10 5.32067
R27 E_SENSE.n13 E_SENSE.n12 5.32067
R28 E_SENSE.n15 E_SENSE.n14 5.32067
R29 E_SENSE.n17 E_SENSE.n16 5.32067
R30 E_SENSE.n19 E_SENSE.n18 5.32067
R31 E_SENSE.n21 E_SENSE.n20 5.32067
R32 E_SENSE.n23 E_SENSE.n22 5.32067
R33 E_SENSE.n25 E_SENSE.n24 5.32067
R34 E_SENSE.n27 E_SENSE.n26 5.32067
R35 E_SENSE.n29 E_SENSE.n28 5.32067
R36 E_SENSE.n62 E_SENSE.n61 4.61063
R37 E_SENSE.n0 E_SENSE.t53 0.228
R38 E_SENSE.n0 E_SENSE.t52 0.228
R39 E_SENSE.n2 E_SENSE.t37 0.228
R40 E_SENSE.n2 E_SENSE.t36 0.228
R41 E_SENSE.n4 E_SENSE.t5 0.228
R42 E_SENSE.n4 E_SENSE.t4 0.228
R43 E_SENSE.n6 E_SENSE.t21 0.228
R44 E_SENSE.n6 E_SENSE.t20 0.228
R45 E_SENSE.n8 E_SENSE.t51 0.228
R46 E_SENSE.n8 E_SENSE.t50 0.228
R47 E_SENSE.n10 E_SENSE.t63 0.228
R48 E_SENSE.n10 E_SENSE.t62 0.228
R49 E_SENSE.n12 E_SENSE.t35 0.228
R50 E_SENSE.n12 E_SENSE.t34 0.228
R51 E_SENSE.n14 E_SENSE.t3 0.228
R52 E_SENSE.n14 E_SENSE.t2 0.228
R53 E_SENSE.n16 E_SENSE.t19 0.228
R54 E_SENSE.n16 E_SENSE.t18 0.228
R55 E_SENSE.n18 E_SENSE.t49 0.228
R56 E_SENSE.n18 E_SENSE.t48 0.228
R57 E_SENSE.n20 E_SENSE.t61 0.228
R58 E_SENSE.n20 E_SENSE.t60 0.228
R59 E_SENSE.n22 E_SENSE.t33 0.228
R60 E_SENSE.n22 E_SENSE.t32 0.228
R61 E_SENSE.n24 E_SENSE.t1 0.228
R62 E_SENSE.n24 E_SENSE.t0 0.228
R63 E_SENSE.n26 E_SENSE.t17 0.228
R64 E_SENSE.n26 E_SENSE.t16 0.228
R65 E_SENSE.n28 E_SENSE.t47 0.228
R66 E_SENSE.n28 E_SENSE.t46 0.228
R67 E_SENSE.n31 E_SENSE.t15 0.20525
R68 E_SENSE.n31 E_SENSE.t14 0.20525
R69 E_SENSE.n33 E_SENSE.t45 0.20525
R70 E_SENSE.n33 E_SENSE.t44 0.20525
R71 E_SENSE.n35 E_SENSE.t13 0.20525
R72 E_SENSE.n35 E_SENSE.t12 0.20525
R73 E_SENSE.n37 E_SENSE.t29 0.20525
R74 E_SENSE.n37 E_SENSE.t28 0.20525
R75 E_SENSE.n39 E_SENSE.t59 0.20525
R76 E_SENSE.n39 E_SENSE.t58 0.20525
R77 E_SENSE.n41 E_SENSE.t43 0.20525
R78 E_SENSE.n41 E_SENSE.t42 0.20525
R79 E_SENSE.n43 E_SENSE.t11 0.20525
R80 E_SENSE.n43 E_SENSE.t10 0.20525
R81 E_SENSE.n45 E_SENSE.t27 0.20525
R82 E_SENSE.n45 E_SENSE.t26 0.20525
R83 E_SENSE.n47 E_SENSE.t57 0.20525
R84 E_SENSE.n47 E_SENSE.t56 0.20525
R85 E_SENSE.n49 E_SENSE.t41 0.20525
R86 E_SENSE.n49 E_SENSE.t40 0.20525
R87 E_SENSE.n51 E_SENSE.t9 0.20525
R88 E_SENSE.n51 E_SENSE.t8 0.20525
R89 E_SENSE.n53 E_SENSE.t25 0.20525
R90 E_SENSE.n53 E_SENSE.t24 0.20525
R91 E_SENSE.n55 E_SENSE.t55 0.20525
R92 E_SENSE.n55 E_SENSE.t54 0.20525
R93 E_SENSE.n57 E_SENSE.t39 0.20525
R94 E_SENSE.n57 E_SENSE.t38 0.20525
R95 E_SENSE.n59 E_SENSE.t7 0.20525
R96 E_SENSE.n59 E_SENSE.t6 0.20525
R97 E_SENSE.n61 E_SENSE.n60 0.189974
R98 E_SENSE.n60 E_SENSE.n58 0.189974
R99 E_SENSE.n58 E_SENSE.n56 0.189974
R100 E_SENSE.n56 E_SENSE.n54 0.189974
R101 E_SENSE.n54 E_SENSE.n52 0.189974
R102 E_SENSE.n52 E_SENSE.n50 0.189974
R103 E_SENSE.n50 E_SENSE.n48 0.189974
R104 E_SENSE.n48 E_SENSE.n46 0.189974
R105 E_SENSE.n46 E_SENSE.n44 0.189974
R106 E_SENSE.n44 E_SENSE.n42 0.189974
R107 E_SENSE.n42 E_SENSE.n40 0.189974
R108 E_SENSE.n40 E_SENSE.n38 0.189974
R109 E_SENSE.n38 E_SENSE.n36 0.189974
R110 E_SENSE.n36 E_SENSE.n34 0.189974
R111 E_SENSE.n34 E_SENSE.n32 0.189974
R112 E_SENSE.n30 E_SENSE.n29 0.189974
R113 E_SENSE.n29 E_SENSE.n27 0.189974
R114 E_SENSE.n27 E_SENSE.n25 0.189974
R115 E_SENSE.n25 E_SENSE.n23 0.189974
R116 E_SENSE.n23 E_SENSE.n21 0.189974
R117 E_SENSE.n21 E_SENSE.n19 0.189974
R118 E_SENSE.n19 E_SENSE.n17 0.189974
R119 E_SENSE.n17 E_SENSE.n15 0.189974
R120 E_SENSE.n15 E_SENSE.n13 0.189974
R121 E_SENSE.n13 E_SENSE.n11 0.189974
R122 E_SENSE.n11 E_SENSE.n9 0.189974
R123 E_SENSE.n9 E_SENSE.n7 0.189974
R124 E_SENSE.n7 E_SENSE.n5 0.189974
R125 E_SENSE.n5 E_SENSE.n3 0.189974
R126 E_SENSE.n3 E_SENSE.n1 0.189974
R127 E_CAPTURE_CLK E_CAPTURE_CLK.n14 7.98157
R128 E_CAPTURE_CLK.n14 E_CAPTURE_CLK.n6 6.5392
R129 E_CAPTURE_CLK.n8 E_CAPTURE_CLK.t0 5.7796
R130 E_CAPTURE_CLK.n1 E_CAPTURE_CLK.t6 5.73764
R131 E_CAPTURE_CLK.n13 E_CAPTURE_CLK.t2 5.59012
R132 E_CAPTURE_CLK.n6 E_CAPTURE_CLK.t4 5.54817
R133 E_CAPTURE_CLK.n8 E_CAPTURE_CLK.n7 5.38537
R134 E_CAPTURE_CLK.n10 E_CAPTURE_CLK.n9 5.38537
R135 E_CAPTURE_CLK.n12 E_CAPTURE_CLK.n11 5.38537
R136 E_CAPTURE_CLK.n1 E_CAPTURE_CLK.n0 5.32067
R137 E_CAPTURE_CLK.n3 E_CAPTURE_CLK.n2 5.32067
R138 E_CAPTURE_CLK.n5 E_CAPTURE_CLK.n4 5.32067
R139 E_CAPTURE_CLK.n14 E_CAPTURE_CLK.n13 4.61063
R140 E_CAPTURE_CLK.n0 E_CAPTURE_CLK.t3 0.228
R141 E_CAPTURE_CLK.n0 E_CAPTURE_CLK.t14 0.228
R142 E_CAPTURE_CLK.n2 E_CAPTURE_CLK.t13 0.228
R143 E_CAPTURE_CLK.n2 E_CAPTURE_CLK.t7 0.228
R144 E_CAPTURE_CLK.n4 E_CAPTURE_CLK.t10 0.228
R145 E_CAPTURE_CLK.n4 E_CAPTURE_CLK.t9 0.228
R146 E_CAPTURE_CLK.n7 E_CAPTURE_CLK.t11 0.20525
R147 E_CAPTURE_CLK.n7 E_CAPTURE_CLK.t12 0.20525
R148 E_CAPTURE_CLK.n9 E_CAPTURE_CLK.t1 0.20525
R149 E_CAPTURE_CLK.n9 E_CAPTURE_CLK.t8 0.20525
R150 E_CAPTURE_CLK.n11 E_CAPTURE_CLK.t15 0.20525
R151 E_CAPTURE_CLK.n11 E_CAPTURE_CLK.t5 0.20525
R152 E_CAPTURE_CLK.n13 E_CAPTURE_CLK.n12 0.189974
R153 E_CAPTURE_CLK.n12 E_CAPTURE_CLK.n10 0.189974
R154 E_CAPTURE_CLK.n10 E_CAPTURE_CLK.n8 0.189974
R155 E_CAPTURE_CLK.n6 E_CAPTURE_CLK.n5 0.189974
R156 E_CAPTURE_CLK.n5 E_CAPTURE_CLK.n3 0.189974
R157 E_CAPTURE_CLK.n3 E_CAPTURE_CLK.n1 0.189974
R158 E_CAPTURE_CLKB E_CAPTURE_CLKB.n14 6.63157
R159 E_CAPTURE_CLKB.n14 E_CAPTURE_CLKB.n6 6.5392
R160 E_CAPTURE_CLKB.n8 E_CAPTURE_CLKB.t3 5.7796
R161 E_CAPTURE_CLKB.n1 E_CAPTURE_CLKB.t15 5.73764
R162 E_CAPTURE_CLKB.n13 E_CAPTURE_CLKB.t5 5.59012
R163 E_CAPTURE_CLKB.n6 E_CAPTURE_CLKB.t14 5.54817
R164 E_CAPTURE_CLKB.n8 E_CAPTURE_CLKB.n7 5.38537
R165 E_CAPTURE_CLKB.n10 E_CAPTURE_CLKB.n9 5.38537
R166 E_CAPTURE_CLKB.n12 E_CAPTURE_CLKB.n11 5.38537
R167 E_CAPTURE_CLKB.n1 E_CAPTURE_CLKB.n0 5.32067
R168 E_CAPTURE_CLKB.n3 E_CAPTURE_CLKB.n2 5.32067
R169 E_CAPTURE_CLKB.n5 E_CAPTURE_CLKB.n4 5.32067
R170 E_CAPTURE_CLKB.n14 E_CAPTURE_CLKB.n13 4.61063
R171 E_CAPTURE_CLKB.n0 E_CAPTURE_CLKB.t13 0.228
R172 E_CAPTURE_CLKB.n0 E_CAPTURE_CLKB.t7 0.228
R173 E_CAPTURE_CLKB.n2 E_CAPTURE_CLKB.t10 0.228
R174 E_CAPTURE_CLKB.n2 E_CAPTURE_CLKB.t8 0.228
R175 E_CAPTURE_CLKB.n4 E_CAPTURE_CLKB.t6 0.228
R176 E_CAPTURE_CLKB.n4 E_CAPTURE_CLKB.t9 0.228
R177 E_CAPTURE_CLKB.n7 E_CAPTURE_CLKB.t4 0.20525
R178 E_CAPTURE_CLKB.n7 E_CAPTURE_CLKB.t1 0.20525
R179 E_CAPTURE_CLKB.n9 E_CAPTURE_CLKB.t0 0.20525
R180 E_CAPTURE_CLKB.n9 E_CAPTURE_CLKB.t2 0.20525
R181 E_CAPTURE_CLKB.n11 E_CAPTURE_CLKB.t11 0.20525
R182 E_CAPTURE_CLKB.n11 E_CAPTURE_CLKB.t12 0.20525
R183 E_CAPTURE_CLKB.n13 E_CAPTURE_CLKB.n12 0.189974
R184 E_CAPTURE_CLKB.n12 E_CAPTURE_CLKB.n10 0.189974
R185 E_CAPTURE_CLKB.n10 E_CAPTURE_CLKB.n8 0.189974
R186 E_CAPTURE_CLKB.n6 E_CAPTURE_CLKB.n5 0.189974
R187 E_CAPTURE_CLKB.n5 E_CAPTURE_CLKB.n3 0.189974
R188 E_CAPTURE_CLKB.n3 E_CAPTURE_CLKB.n1 0.189974
R189 CLKP_H.n8 CLKP_H.t3 113.632
R190 CLKP_H.n5 CLKP_H.t0 113.632
R191 CLKP_H.n0 CLKP_H.t4 113.632
R192 CLKP_H.n3 CLKP_H.t7 113.632
R193 CLKP_H.n6 CLKP_H.t1 109.174
R194 CLKP_H.n7 CLKP_H.t2 109.174
R195 CLKP_H.n1 CLKP_H.t5 109.174
R196 CLKP_H.n2 CLKP_H.t6 109.174
R197 CLKP_H CLKP_H.n10 15.3874
R198 CLKP_H.n7 CLKP_H.n6 11.6805
R199 CLKP_H.n2 CLKP_H.n1 11.6805
R200 CLKP_H.n10 CLKP_H.n4 10.9291
R201 CLKP_H.n10 CLKP_H.n9 9.0005
R202 CLKP_H.n9 CLKP_H.n5 7.10487
R203 CLKP_H.n9 CLKP_H.n8 7.10487
R204 CLKP_H.n4 CLKP_H.n0 7.10487
R205 CLKP_H.n4 CLKP_H.n3 7.10487
R206 CLKP_H.n6 CLKP_H.n5 4.42851
R207 CLKP_H.n8 CLKP_H.n7 4.42851
R208 CLKP_H.n1 CLKP_H.n0 4.42851
R209 CLKP_H.n3 CLKP_H.n2 4.42851
R210 CLKP_HB.n15 CLKP_HB.t7 113.632
R211 CLKP_HB.n19 CLKP_HB.t0 113.632
R212 CLKP_HB.n2 CLKP_HB.t19 113.632
R213 CLKP_HB.n6 CLKP_HB.t12 113.632
R214 CLKP_HB.n35 CLKP_HB.t11 113.632
R215 CLKP_HB.n32 CLKP_HB.t8 113.632
R216 CLKP_HB.n27 CLKP_HB.t20 113.632
R217 CLKP_HB.n30 CLKP_HB.t23 113.632
R218 CLKP_HB.n22 CLKP_HB.t3 109.174
R219 CLKP_HB.n23 CLKP_HB.t4 109.174
R220 CLKP_HB.n16 CLKP_HB.t6 109.174
R221 CLKP_HB.n17 CLKP_HB.t5 109.174
R222 CLKP_HB.n21 CLKP_HB.t2 109.174
R223 CLKP_HB.n18 CLKP_HB.t1 109.174
R224 CLKP_HB.n9 CLKP_HB.t15 109.174
R225 CLKP_HB.n10 CLKP_HB.t16 109.174
R226 CLKP_HB.n3 CLKP_HB.t18 109.174
R227 CLKP_HB.n4 CLKP_HB.t17 109.174
R228 CLKP_HB.n8 CLKP_HB.t14 109.174
R229 CLKP_HB.n5 CLKP_HB.t13 109.174
R230 CLKP_HB.n33 CLKP_HB.t9 109.174
R231 CLKP_HB.n34 CLKP_HB.t10 109.174
R232 CLKP_HB.n28 CLKP_HB.t21 109.174
R233 CLKP_HB.n29 CLKP_HB.t22 109.174
R234 CLKP_HB.n22 CLKP_HB.n13 18.4942
R235 CLKP_HB.n24 CLKP_HB.n23 18.4942
R236 CLKP_HB.n17 CLKP_HB.n14 18.4942
R237 CLKP_HB.n21 CLKP_HB.n20 18.4942
R238 CLKP_HB.n9 CLKP_HB.n0 18.4942
R239 CLKP_HB.n11 CLKP_HB.n10 18.4942
R240 CLKP_HB.n4 CLKP_HB.n1 18.4942
R241 CLKP_HB.n8 CLKP_HB.n7 18.4942
R242 CLKP_HB.n22 CLKP_HB.n21 11.6805
R243 CLKP_HB.n23 CLKP_HB.n22 11.6805
R244 CLKP_HB.n17 CLKP_HB.n16 11.6805
R245 CLKP_HB.n23 CLKP_HB.n17 11.6805
R246 CLKP_HB.n21 CLKP_HB.n18 11.6805
R247 CLKP_HB.n9 CLKP_HB.n8 11.6805
R248 CLKP_HB.n10 CLKP_HB.n9 11.6805
R249 CLKP_HB.n4 CLKP_HB.n3 11.6805
R250 CLKP_HB.n10 CLKP_HB.n4 11.6805
R251 CLKP_HB.n8 CLKP_HB.n5 11.6805
R252 CLKP_HB.n34 CLKP_HB.n33 11.6805
R253 CLKP_HB.n29 CLKP_HB.n28 11.6805
R254 CLKP_HB.n26 CLKP_HB.n12 10.9291
R255 CLKP_HB.n37 CLKP_HB.n31 10.9291
R256 CLKP_HB.n38 CLKP_HB.n26 9.02258
R257 CLKP_HB.n26 CLKP_HB.n25 9.0005
R258 CLKP_HB.n37 CLKP_HB.n36 9.0005
R259 CLKP_HB CLKP_HB.n38 8.25354
R260 CLKP_HB.n20 CLKP_HB.n19 7.17687
R261 CLKP_HB.n15 CLKP_HB.n14 7.17687
R262 CLKP_HB.n7 CLKP_HB.n6 7.17687
R263 CLKP_HB.n2 CLKP_HB.n1 7.17687
R264 CLKP_HB.n36 CLKP_HB.n32 7.10487
R265 CLKP_HB.n36 CLKP_HB.n35 7.10487
R266 CLKP_HB.n31 CLKP_HB.n27 7.10487
R267 CLKP_HB.n31 CLKP_HB.n30 7.10487
R268 CLKP_HB.n38 CLKP_HB.n37 4.59693
R269 CLKP_HB.n16 CLKP_HB.n15 4.42851
R270 CLKP_HB.n19 CLKP_HB.n18 4.42851
R271 CLKP_HB.n3 CLKP_HB.n2 4.42851
R272 CLKP_HB.n6 CLKP_HB.n5 4.42851
R273 CLKP_HB.n33 CLKP_HB.n32 4.42851
R274 CLKP_HB.n35 CLKP_HB.n34 4.42851
R275 CLKP_HB.n28 CLKP_HB.n27 4.42851
R276 CLKP_HB.n30 CLKP_HB.n29 4.42851
R277 CLKP_HB.n20 CLKP_HB.n13 0.1205
R278 CLKP_HB.n24 CLKP_HB.n14 0.1205
R279 CLKP_HB.n7 CLKP_HB.n0 0.1205
R280 CLKP_HB.n11 CLKP_HB.n1 0.1205
R281 CLKP_HB.n25 CLKP_HB.n13 0.0485
R282 CLKP_HB.n25 CLKP_HB.n24 0.0485
R283 CLKP_HB.n12 CLKP_HB.n0 0.0485
R284 CLKP_HB.n12 CLKP_HB.n11 0.0485
R285 O_SENSE O_SENSE.n62 11.7381
R286 O_SENSE.n62 O_SENSE.n30 6.5392
R287 O_SENSE.n32 O_SENSE.t58 5.7796
R288 O_SENSE.n1 O_SENSE.t27 5.73764
R289 O_SENSE.n61 O_SENSE.t32 5.59012
R290 O_SENSE.n30 O_SENSE.t59 5.54817
R291 O_SENSE.n32 O_SENSE.n31 5.38537
R292 O_SENSE.n34 O_SENSE.n33 5.38537
R293 O_SENSE.n36 O_SENSE.n35 5.38537
R294 O_SENSE.n38 O_SENSE.n37 5.38537
R295 O_SENSE.n40 O_SENSE.n39 5.38537
R296 O_SENSE.n42 O_SENSE.n41 5.38537
R297 O_SENSE.n44 O_SENSE.n43 5.38537
R298 O_SENSE.n46 O_SENSE.n45 5.38537
R299 O_SENSE.n48 O_SENSE.n47 5.38537
R300 O_SENSE.n50 O_SENSE.n49 5.38537
R301 O_SENSE.n52 O_SENSE.n51 5.38537
R302 O_SENSE.n54 O_SENSE.n53 5.38537
R303 O_SENSE.n56 O_SENSE.n55 5.38537
R304 O_SENSE.n58 O_SENSE.n57 5.38537
R305 O_SENSE.n60 O_SENSE.n59 5.38537
R306 O_SENSE.n1 O_SENSE.n0 5.32067
R307 O_SENSE.n3 O_SENSE.n2 5.32067
R308 O_SENSE.n5 O_SENSE.n4 5.32067
R309 O_SENSE.n7 O_SENSE.n6 5.32067
R310 O_SENSE.n9 O_SENSE.n8 5.32067
R311 O_SENSE.n11 O_SENSE.n10 5.32067
R312 O_SENSE.n13 O_SENSE.n12 5.32067
R313 O_SENSE.n15 O_SENSE.n14 5.32067
R314 O_SENSE.n17 O_SENSE.n16 5.32067
R315 O_SENSE.n19 O_SENSE.n18 5.32067
R316 O_SENSE.n21 O_SENSE.n20 5.32067
R317 O_SENSE.n23 O_SENSE.n22 5.32067
R318 O_SENSE.n25 O_SENSE.n24 5.32067
R319 O_SENSE.n27 O_SENSE.n26 5.32067
R320 O_SENSE.n29 O_SENSE.n28 5.32067
R321 O_SENSE.n62 O_SENSE.n61 4.61063
R322 O_SENSE.n0 O_SENSE.t8 0.228
R323 O_SENSE.n0 O_SENSE.t21 0.228
R324 O_SENSE.n2 O_SENSE.t2 0.228
R325 O_SENSE.n2 O_SENSE.t41 0.228
R326 O_SENSE.n4 O_SENSE.t38 0.228
R327 O_SENSE.n4 O_SENSE.t15 0.228
R328 O_SENSE.n6 O_SENSE.t43 0.228
R329 O_SENSE.n6 O_SENSE.t55 0.228
R330 O_SENSE.n8 O_SENSE.t30 0.228
R331 O_SENSE.n8 O_SENSE.t61 0.228
R332 O_SENSE.n10 O_SENSE.t40 0.228
R333 O_SENSE.n10 O_SENSE.t26 0.228
R334 O_SENSE.n12 O_SENSE.t54 0.228
R335 O_SENSE.n12 O_SENSE.t37 0.228
R336 O_SENSE.n14 O_SENSE.t33 0.228
R337 O_SENSE.n14 O_SENSE.t35 0.228
R338 O_SENSE.n16 O_SENSE.t7 0.228
R339 O_SENSE.n16 O_SENSE.t20 0.228
R340 O_SENSE.n18 O_SENSE.t14 0.228
R341 O_SENSE.n18 O_SENSE.t1 0.228
R342 O_SENSE.n20 O_SENSE.t19 0.228
R343 O_SENSE.n20 O_SENSE.t46 0.228
R344 O_SENSE.n22 O_SENSE.t0 0.228
R345 O_SENSE.n22 O_SENSE.t6 0.228
R346 O_SENSE.n24 O_SENSE.t18 0.228
R347 O_SENSE.n24 O_SENSE.t13 0.228
R348 O_SENSE.n26 O_SENSE.t48 0.228
R349 O_SENSE.n26 O_SENSE.t5 0.228
R350 O_SENSE.n28 O_SENSE.t53 0.228
R351 O_SENSE.n28 O_SENSE.t50 0.228
R352 O_SENSE.n31 O_SENSE.t60 0.20525
R353 O_SENSE.n31 O_SENSE.t45 0.20525
R354 O_SENSE.n33 O_SENSE.t42 0.20525
R355 O_SENSE.n33 O_SENSE.t31 0.20525
R356 O_SENSE.n35 O_SENSE.t57 0.20525
R357 O_SENSE.n35 O_SENSE.t39 0.20525
R358 O_SENSE.n37 O_SENSE.t34 0.20525
R359 O_SENSE.n37 O_SENSE.t36 0.20525
R360 O_SENSE.n39 O_SENSE.t12 0.20525
R361 O_SENSE.n39 O_SENSE.t25 0.20525
R362 O_SENSE.n41 O_SENSE.t17 0.20525
R363 O_SENSE.n41 O_SENSE.t4 0.20525
R364 O_SENSE.n43 O_SENSE.t24 0.20525
R365 O_SENSE.n43 O_SENSE.t49 0.20525
R366 O_SENSE.n45 O_SENSE.t3 0.20525
R367 O_SENSE.n45 O_SENSE.t11 0.20525
R368 O_SENSE.n47 O_SENSE.t23 0.20525
R369 O_SENSE.n47 O_SENSE.t16 0.20525
R370 O_SENSE.n49 O_SENSE.t47 0.20525
R371 O_SENSE.n49 O_SENSE.t10 0.20525
R372 O_SENSE.n51 O_SENSE.t29 0.20525
R373 O_SENSE.n51 O_SENSE.t51 0.20525
R374 O_SENSE.n53 O_SENSE.t63 0.20525
R375 O_SENSE.n53 O_SENSE.t56 0.20525
R376 O_SENSE.n55 O_SENSE.t22 0.20525
R377 O_SENSE.n55 O_SENSE.t28 0.20525
R378 O_SENSE.n57 O_SENSE.t52 0.20525
R379 O_SENSE.n57 O_SENSE.t9 0.20525
R380 O_SENSE.n59 O_SENSE.t62 0.20525
R381 O_SENSE.n59 O_SENSE.t44 0.20525
R382 O_SENSE.n61 O_SENSE.n60 0.189974
R383 O_SENSE.n60 O_SENSE.n58 0.189974
R384 O_SENSE.n58 O_SENSE.n56 0.189974
R385 O_SENSE.n56 O_SENSE.n54 0.189974
R386 O_SENSE.n54 O_SENSE.n52 0.189974
R387 O_SENSE.n52 O_SENSE.n50 0.189974
R388 O_SENSE.n50 O_SENSE.n48 0.189974
R389 O_SENSE.n48 O_SENSE.n46 0.189974
R390 O_SENSE.n46 O_SENSE.n44 0.189974
R391 O_SENSE.n44 O_SENSE.n42 0.189974
R392 O_SENSE.n42 O_SENSE.n40 0.189974
R393 O_SENSE.n40 O_SENSE.n38 0.189974
R394 O_SENSE.n38 O_SENSE.n36 0.189974
R395 O_SENSE.n36 O_SENSE.n34 0.189974
R396 O_SENSE.n34 O_SENSE.n32 0.189974
R397 O_SENSE.n30 O_SENSE.n29 0.189974
R398 O_SENSE.n29 O_SENSE.n27 0.189974
R399 O_SENSE.n27 O_SENSE.n25 0.189974
R400 O_SENSE.n25 O_SENSE.n23 0.189974
R401 O_SENSE.n23 O_SENSE.n21 0.189974
R402 O_SENSE.n21 O_SENSE.n19 0.189974
R403 O_SENSE.n19 O_SENSE.n17 0.189974
R404 O_SENSE.n17 O_SENSE.n15 0.189974
R405 O_SENSE.n15 O_SENSE.n13 0.189974
R406 O_SENSE.n13 O_SENSE.n11 0.189974
R407 O_SENSE.n11 O_SENSE.n9 0.189974
R408 O_SENSE.n9 O_SENSE.n7 0.189974
R409 O_SENSE.n7 O_SENSE.n5 0.189974
R410 O_SENSE.n5 O_SENSE.n3 0.189974
R411 O_SENSE.n3 O_SENSE.n1 0.189974
R412 O_CAPTURE_CLK O_CAPTURE_CLK.n14 7.98157
R413 O_CAPTURE_CLK.n14 O_CAPTURE_CLK.n6 6.5392
R414 O_CAPTURE_CLK.n8 O_CAPTURE_CLK.t12 5.7796
R415 O_CAPTURE_CLK.n1 O_CAPTURE_CLK.t14 5.73764
R416 O_CAPTURE_CLK.n13 O_CAPTURE_CLK.t3 5.59012
R417 O_CAPTURE_CLK.n6 O_CAPTURE_CLK.t1 5.54817
R418 O_CAPTURE_CLK.n8 O_CAPTURE_CLK.n7 5.38537
R419 O_CAPTURE_CLK.n10 O_CAPTURE_CLK.n9 5.38537
R420 O_CAPTURE_CLK.n12 O_CAPTURE_CLK.n11 5.38537
R421 O_CAPTURE_CLK.n1 O_CAPTURE_CLK.n0 5.32067
R422 O_CAPTURE_CLK.n3 O_CAPTURE_CLK.n2 5.32067
R423 O_CAPTURE_CLK.n5 O_CAPTURE_CLK.n4 5.32067
R424 O_CAPTURE_CLK.n14 O_CAPTURE_CLK.n13 4.61063
R425 O_CAPTURE_CLK.n0 O_CAPTURE_CLK.t8 0.228
R426 O_CAPTURE_CLK.n0 O_CAPTURE_CLK.t15 0.228
R427 O_CAPTURE_CLK.n2 O_CAPTURE_CLK.t4 0.228
R428 O_CAPTURE_CLK.n2 O_CAPTURE_CLK.t9 0.228
R429 O_CAPTURE_CLK.n4 O_CAPTURE_CLK.t0 0.228
R430 O_CAPTURE_CLK.n4 O_CAPTURE_CLK.t5 0.228
R431 O_CAPTURE_CLK.n7 O_CAPTURE_CLK.t10 0.20525
R432 O_CAPTURE_CLK.n7 O_CAPTURE_CLK.t13 0.20525
R433 O_CAPTURE_CLK.n9 O_CAPTURE_CLK.t6 0.20525
R434 O_CAPTURE_CLK.n9 O_CAPTURE_CLK.t11 0.20525
R435 O_CAPTURE_CLK.n11 O_CAPTURE_CLK.t2 0.20525
R436 O_CAPTURE_CLK.n11 O_CAPTURE_CLK.t7 0.20525
R437 O_CAPTURE_CLK.n13 O_CAPTURE_CLK.n12 0.189974
R438 O_CAPTURE_CLK.n12 O_CAPTURE_CLK.n10 0.189974
R439 O_CAPTURE_CLK.n10 O_CAPTURE_CLK.n8 0.189974
R440 O_CAPTURE_CLK.n6 O_CAPTURE_CLK.n5 0.189974
R441 O_CAPTURE_CLK.n5 O_CAPTURE_CLK.n3 0.189974
R442 O_CAPTURE_CLK.n3 O_CAPTURE_CLK.n1 0.189974
R443 O_CAPTURE_CLKB O_CAPTURE_CLKB.n14 6.63157
R444 O_CAPTURE_CLKB.n14 O_CAPTURE_CLKB.n6 6.5392
R445 O_CAPTURE_CLKB.n8 O_CAPTURE_CLKB.t6 5.7796
R446 O_CAPTURE_CLKB.n1 O_CAPTURE_CLKB.t9 5.73764
R447 O_CAPTURE_CLKB.n13 O_CAPTURE_CLKB.t3 5.59012
R448 O_CAPTURE_CLKB.n6 O_CAPTURE_CLKB.t8 5.54817
R449 O_CAPTURE_CLKB.n8 O_CAPTURE_CLKB.n7 5.38537
R450 O_CAPTURE_CLKB.n10 O_CAPTURE_CLKB.n9 5.38537
R451 O_CAPTURE_CLKB.n12 O_CAPTURE_CLKB.n11 5.38537
R452 O_CAPTURE_CLKB.n1 O_CAPTURE_CLKB.n0 5.32067
R453 O_CAPTURE_CLKB.n3 O_CAPTURE_CLKB.n2 5.32067
R454 O_CAPTURE_CLKB.n5 O_CAPTURE_CLKB.n4 5.32067
R455 O_CAPTURE_CLKB.n14 O_CAPTURE_CLKB.n13 4.61063
R456 O_CAPTURE_CLKB.n0 O_CAPTURE_CLKB.t14 0.228
R457 O_CAPTURE_CLKB.n0 O_CAPTURE_CLKB.t10 0.228
R458 O_CAPTURE_CLKB.n2 O_CAPTURE_CLKB.t0 0.228
R459 O_CAPTURE_CLKB.n2 O_CAPTURE_CLKB.t15 0.228
R460 O_CAPTURE_CLKB.n4 O_CAPTURE_CLKB.t7 0.228
R461 O_CAPTURE_CLKB.n4 O_CAPTURE_CLKB.t1 0.228
R462 O_CAPTURE_CLKB.n7 O_CAPTURE_CLKB.t4 0.20525
R463 O_CAPTURE_CLKB.n7 O_CAPTURE_CLKB.t13 0.20525
R464 O_CAPTURE_CLKB.n9 O_CAPTURE_CLKB.t11 0.20525
R465 O_CAPTURE_CLKB.n9 O_CAPTURE_CLKB.t5 0.20525
R466 O_CAPTURE_CLKB.n11 O_CAPTURE_CLKB.t2 0.20525
R467 O_CAPTURE_CLKB.n11 O_CAPTURE_CLKB.t12 0.20525
R468 O_CAPTURE_CLKB.n13 O_CAPTURE_CLKB.n12 0.189974
R469 O_CAPTURE_CLKB.n12 O_CAPTURE_CLKB.n10 0.189974
R470 O_CAPTURE_CLKB.n10 O_CAPTURE_CLKB.n8 0.189974
R471 O_CAPTURE_CLKB.n6 O_CAPTURE_CLKB.n5 0.189974
R472 O_CAPTURE_CLKB.n5 O_CAPTURE_CLKB.n3 0.189974
R473 O_CAPTURE_CLKB.n3 O_CAPTURE_CLKB.n1 0.189974
R474 CLKN_H.n8 CLKN_H.t3 113.632
R475 CLKN_H.n5 CLKN_H.t0 113.632
R476 CLKN_H.n0 CLKN_H.t4 113.632
R477 CLKN_H.n3 CLKN_H.t7 113.632
R478 CLKN_H.n6 CLKN_H.t1 109.174
R479 CLKN_H.n7 CLKN_H.t2 109.174
R480 CLKN_H.n1 CLKN_H.t5 109.174
R481 CLKN_H.n2 CLKN_H.t6 109.174
R482 CLKN_H CLKN_H.n10 15.3874
R483 CLKN_H.n7 CLKN_H.n6 11.6805
R484 CLKN_H.n2 CLKN_H.n1 11.6805
R485 CLKN_H.n10 CLKN_H.n4 10.9291
R486 CLKN_H.n10 CLKN_H.n9 9.0005
R487 CLKN_H.n9 CLKN_H.n5 7.10487
R488 CLKN_H.n9 CLKN_H.n8 7.10487
R489 CLKN_H.n4 CLKN_H.n0 7.10487
R490 CLKN_H.n4 CLKN_H.n3 7.10487
R491 CLKN_H.n6 CLKN_H.n5 4.42851
R492 CLKN_H.n8 CLKN_H.n7 4.42851
R493 CLKN_H.n1 CLKN_H.n0 4.42851
R494 CLKN_H.n3 CLKN_H.n2 4.42851
R495 CLKN_HB.n15 CLKN_HB.t7 113.632
R496 CLKN_HB.n19 CLKN_HB.t0 113.632
R497 CLKN_HB.n2 CLKN_HB.t19 113.632
R498 CLKN_HB.n6 CLKN_HB.t12 113.632
R499 CLKN_HB.n35 CLKN_HB.t11 113.632
R500 CLKN_HB.n32 CLKN_HB.t8 113.632
R501 CLKN_HB.n27 CLKN_HB.t20 113.632
R502 CLKN_HB.n30 CLKN_HB.t23 113.632
R503 CLKN_HB.n22 CLKN_HB.t3 109.174
R504 CLKN_HB.n23 CLKN_HB.t4 109.174
R505 CLKN_HB.n16 CLKN_HB.t6 109.174
R506 CLKN_HB.n17 CLKN_HB.t5 109.174
R507 CLKN_HB.n21 CLKN_HB.t2 109.174
R508 CLKN_HB.n18 CLKN_HB.t1 109.174
R509 CLKN_HB.n9 CLKN_HB.t15 109.174
R510 CLKN_HB.n10 CLKN_HB.t16 109.174
R511 CLKN_HB.n3 CLKN_HB.t18 109.174
R512 CLKN_HB.n4 CLKN_HB.t17 109.174
R513 CLKN_HB.n8 CLKN_HB.t14 109.174
R514 CLKN_HB.n5 CLKN_HB.t13 109.174
R515 CLKN_HB.n33 CLKN_HB.t9 109.174
R516 CLKN_HB.n34 CLKN_HB.t10 109.174
R517 CLKN_HB.n28 CLKN_HB.t21 109.174
R518 CLKN_HB.n29 CLKN_HB.t22 109.174
R519 CLKN_HB.n22 CLKN_HB.n13 18.4942
R520 CLKN_HB.n24 CLKN_HB.n23 18.4942
R521 CLKN_HB.n17 CLKN_HB.n14 18.4942
R522 CLKN_HB.n21 CLKN_HB.n20 18.4942
R523 CLKN_HB.n9 CLKN_HB.n0 18.4942
R524 CLKN_HB.n11 CLKN_HB.n10 18.4942
R525 CLKN_HB.n4 CLKN_HB.n1 18.4942
R526 CLKN_HB.n8 CLKN_HB.n7 18.4942
R527 CLKN_HB.n22 CLKN_HB.n21 11.6805
R528 CLKN_HB.n23 CLKN_HB.n22 11.6805
R529 CLKN_HB.n17 CLKN_HB.n16 11.6805
R530 CLKN_HB.n23 CLKN_HB.n17 11.6805
R531 CLKN_HB.n21 CLKN_HB.n18 11.6805
R532 CLKN_HB.n9 CLKN_HB.n8 11.6805
R533 CLKN_HB.n10 CLKN_HB.n9 11.6805
R534 CLKN_HB.n4 CLKN_HB.n3 11.6805
R535 CLKN_HB.n10 CLKN_HB.n4 11.6805
R536 CLKN_HB.n8 CLKN_HB.n5 11.6805
R537 CLKN_HB.n34 CLKN_HB.n33 11.6805
R538 CLKN_HB.n29 CLKN_HB.n28 11.6805
R539 CLKN_HB.n26 CLKN_HB.n12 10.9291
R540 CLKN_HB.n37 CLKN_HB.n31 10.9291
R541 CLKN_HB CLKN_HB.n38 9.03615
R542 CLKN_HB.n38 CLKN_HB.n26 9.02258
R543 CLKN_HB.n26 CLKN_HB.n25 9.0005
R544 CLKN_HB.n37 CLKN_HB.n36 9.0005
R545 CLKN_HB.n20 CLKN_HB.n19 7.17687
R546 CLKN_HB.n15 CLKN_HB.n14 7.17687
R547 CLKN_HB.n7 CLKN_HB.n6 7.17687
R548 CLKN_HB.n2 CLKN_HB.n1 7.17687
R549 CLKN_HB.n36 CLKN_HB.n32 7.10487
R550 CLKN_HB.n36 CLKN_HB.n35 7.10487
R551 CLKN_HB.n31 CLKN_HB.n27 7.10487
R552 CLKN_HB.n31 CLKN_HB.n30 7.10487
R553 CLKN_HB.n38 CLKN_HB.n37 4.59693
R554 CLKN_HB.n16 CLKN_HB.n15 4.42851
R555 CLKN_HB.n19 CLKN_HB.n18 4.42851
R556 CLKN_HB.n3 CLKN_HB.n2 4.42851
R557 CLKN_HB.n6 CLKN_HB.n5 4.42851
R558 CLKN_HB.n33 CLKN_HB.n32 4.42851
R559 CLKN_HB.n35 CLKN_HB.n34 4.42851
R560 CLKN_HB.n28 CLKN_HB.n27 4.42851
R561 CLKN_HB.n30 CLKN_HB.n29 4.42851
R562 CLKN_HB.n20 CLKN_HB.n13 0.1205
R563 CLKN_HB.n24 CLKN_HB.n14 0.1205
R564 CLKN_HB.n7 CLKN_HB.n0 0.1205
R565 CLKN_HB.n11 CLKN_HB.n1 0.1205
R566 CLKN_HB.n25 CLKN_HB.n13 0.0485
R567 CLKN_HB.n25 CLKN_HB.n24 0.0485
R568 CLKN_HB.n12 CLKN_HB.n0 0.0485
R569 CLKN_HB.n12 CLKN_HB.n11 0.0485
R570 VDD.t112 VDD.t10 450.829
R571 VDD.t16 VDD.t114 450.829
R572 VDD.t126 VDD.t76 450.829
R573 VDD.t78 VDD.t222 450.829
R574 VDD.t336 VDD.t18 450.829
R575 VDD.t218 VDD.t342 450.829
R576 VDD.t304 VDD.t54 450.829
R577 VDD.t60 VDD.t308 450.829
R578 VDD.t318 VDD.t348 450.829
R579 VDD.t350 VDD.t142 450.829
R580 VDD.t172 VDD.t320 450.829
R581 VDD.t144 VDD.t154 450.829
R582 VDD.n177 VDD.t104 417.582
R583 VDD.n88 VDD.t298 417.582
R584 VDD.t104 VDD.t106 44.1994
R585 VDD.t106 VDD.t108 44.1994
R586 VDD.t108 VDD.t112 44.1994
R587 VDD.t10 VDD.t12 44.1994
R588 VDD.t12 VDD.t14 44.1994
R589 VDD.t14 VDD.t16 44.1994
R590 VDD.t114 VDD.t116 44.1994
R591 VDD.t116 VDD.t118 44.1994
R592 VDD.t118 VDD.t120 44.1994
R593 VDD.t120 VDD.t110 44.1994
R594 VDD.t110 VDD.t122 44.1994
R595 VDD.t122 VDD.t124 44.1994
R596 VDD.t124 VDD.t126 44.1994
R597 VDD.t76 VDD.t74 44.1994
R598 VDD.t74 VDD.t24 44.1994
R599 VDD.t24 VDD.t22 44.1994
R600 VDD.t22 VDD.t204 44.1994
R601 VDD.t204 VDD.t202 44.1994
R602 VDD.t202 VDD.t80 44.1994
R603 VDD.t80 VDD.t78 44.1994
R604 VDD.t222 VDD.t220 44.1994
R605 VDD.t220 VDD.t236 44.1994
R606 VDD.t236 VDD.t234 44.1994
R607 VDD.t234 VDD.t246 44.1994
R608 VDD.t246 VDD.t244 44.1994
R609 VDD.t244 VDD.t338 44.1994
R610 VDD.t338 VDD.t336 44.1994
R611 VDD.t18 VDD.t128 44.1994
R612 VDD.t128 VDD.t98 44.1994
R613 VDD.t98 VDD.t62 44.1994
R614 VDD.t62 VDD.t210 44.1994
R615 VDD.t210 VDD.t330 44.1994
R616 VDD.t330 VDD.t216 44.1994
R617 VDD.t216 VDD.t20 44.1994
R618 VDD.t20 VDD.t228 44.1994
R619 VDD.t228 VDD.t132 44.1994
R620 VDD.t132 VDD.t130 44.1994
R621 VDD.t130 VDD.t102 44.1994
R622 VDD.t102 VDD.t100 44.1994
R623 VDD.t100 VDD.t66 44.1994
R624 VDD.t66 VDD.t64 44.1994
R625 VDD.t64 VDD.t196 44.1994
R626 VDD.t196 VDD.t194 44.1994
R627 VDD.t194 VDD.t242 44.1994
R628 VDD.t242 VDD.t240 44.1994
R629 VDD.t240 VDD.t200 44.1994
R630 VDD.t200 VDD.t198 44.1994
R631 VDD.t198 VDD.t334 44.1994
R632 VDD.t334 VDD.t332 44.1994
R633 VDD.t332 VDD.t218 44.1994
R634 VDD.t342 VDD.t322 44.1994
R635 VDD.t322 VDD.t272 44.1994
R636 VDD.t272 VDD.t252 44.1994
R637 VDD.t252 VDD.t38 44.1994
R638 VDD.t38 VDD.t134 44.1994
R639 VDD.t134 VDD.t68 44.1994
R640 VDD.t68 VDD.t0 44.1994
R641 VDD.t0 VDD.t40 44.1994
R642 VDD.t40 VDD.t136 44.1994
R643 VDD.t136 VDD.t248 44.1994
R644 VDD.t248 VDD.t70 44.1994
R645 VDD.t70 VDD.t2 44.1994
R646 VDD.t2 VDD.t42 44.1994
R647 VDD.t42 VDD.t138 44.1994
R648 VDD.t138 VDD.t206 44.1994
R649 VDD.t206 VDD.t208 44.1994
R650 VDD.t208 VDD.t324 44.1994
R651 VDD.t324 VDD.t212 44.1994
R652 VDD.t212 VDD.t224 44.1994
R653 VDD.t224 VDD.t168 44.1994
R654 VDD.t168 VDD.t192 44.1994
R655 VDD.t192 VDD.t344 44.1994
R656 VDD.t344 VDD.t238 44.1994
R657 VDD.t238 VDD.t326 44.1994
R658 VDD.t326 VDD.t214 44.1994
R659 VDD.t214 VDD.t72 44.1994
R660 VDD.t72 VDD.t4 44.1994
R661 VDD.t4 VDD.t226 44.1994
R662 VDD.t226 VDD.t44 44.1994
R663 VDD.t44 VDD.t140 44.1994
R664 VDD.t140 VDD.t170 44.1994
R665 VDD.t298 VDD.t300 44.1994
R666 VDD.t300 VDD.t302 44.1994
R667 VDD.t302 VDD.t304 44.1994
R668 VDD.t54 VDD.t56 44.1994
R669 VDD.t56 VDD.t58 44.1994
R670 VDD.t58 VDD.t60 44.1994
R671 VDD.t308 VDD.t310 44.1994
R672 VDD.t310 VDD.t312 44.1994
R673 VDD.t312 VDD.t306 44.1994
R674 VDD.t306 VDD.t296 44.1994
R675 VDD.t296 VDD.t314 44.1994
R676 VDD.t314 VDD.t316 44.1994
R677 VDD.t316 VDD.t318 44.1994
R678 VDD.t348 VDD.t230 44.1994
R679 VDD.t230 VDD.t260 44.1994
R680 VDD.t260 VDD.t262 44.1994
R681 VDD.t262 VDD.t258 44.1994
R682 VDD.t258 VDD.t346 44.1994
R683 VDD.t346 VDD.t232 44.1994
R684 VDD.t232 VDD.t350 44.1994
R685 VDD.t142 VDD.t274 44.1994
R686 VDD.t274 VDD.t250 44.1994
R687 VDD.t250 VDD.t328 44.1994
R688 VDD.t328 VDD.t174 44.1994
R689 VDD.t174 VDD.t96 44.1994
R690 VDD.t96 VDD.t340 44.1994
R691 VDD.t340 VDD.t172 44.1994
R692 VDD.t320 VDD.t152 44.1994
R693 VDD.t152 VDD.t150 44.1994
R694 VDD.t150 VDD.t8 44.1994
R695 VDD.t8 VDD.t6 44.1994
R696 VDD.t6 VDD.t278 44.1994
R697 VDD.t278 VDD.t276 44.1994
R698 VDD.t276 VDD.t48 44.1994
R699 VDD.t48 VDD.t46 44.1994
R700 VDD.t46 VDD.t282 44.1994
R701 VDD.t282 VDD.t280 44.1994
R702 VDD.t280 VDD.t148 44.1994
R703 VDD.t148 VDD.t146 44.1994
R704 VDD.t146 VDD.t256 44.1994
R705 VDD.t256 VDD.t254 44.1994
R706 VDD.t254 VDD.t290 44.1994
R707 VDD.t290 VDD.t288 44.1994
R708 VDD.t288 VDD.t286 44.1994
R709 VDD.t286 VDD.t284 44.1994
R710 VDD.t284 VDD.t294 44.1994
R711 VDD.t294 VDD.t292 44.1994
R712 VDD.t292 VDD.t52 44.1994
R713 VDD.t52 VDD.t50 44.1994
R714 VDD.t50 VDD.t144 44.1994
R715 VDD.t154 VDD.t178 44.1994
R716 VDD.t178 VDD.t176 44.1994
R717 VDD.t176 VDD.t84 44.1994
R718 VDD.t84 VDD.t82 44.1994
R719 VDD.t82 VDD.t28 44.1994
R720 VDD.t28 VDD.t26 44.1994
R721 VDD.t26 VDD.t158 44.1994
R722 VDD.t158 VDD.t156 44.1994
R723 VDD.t156 VDD.t266 44.1994
R724 VDD.t266 VDD.t264 44.1994
R725 VDD.t264 VDD.t182 44.1994
R726 VDD.t182 VDD.t180 44.1994
R727 VDD.t180 VDD.t88 44.1994
R728 VDD.t88 VDD.t86 44.1994
R729 VDD.t86 VDD.t32 44.1994
R730 VDD.t32 VDD.t30 44.1994
R731 VDD.t30 VDD.t162 44.1994
R732 VDD.t162 VDD.t160 44.1994
R733 VDD.t160 VDD.t270 44.1994
R734 VDD.t270 VDD.t268 44.1994
R735 VDD.t268 VDD.t186 44.1994
R736 VDD.t186 VDD.t184 44.1994
R737 VDD.t184 VDD.t92 44.1994
R738 VDD.t92 VDD.t90 44.1994
R739 VDD.t90 VDD.t36 44.1994
R740 VDD.t36 VDD.t34 44.1994
R741 VDD.t34 VDD.t166 44.1994
R742 VDD.t166 VDD.t164 44.1994
R743 VDD.t164 VDD.t190 44.1994
R744 VDD.t190 VDD.t188 44.1994
R745 VDD.t188 VDD.t94 44.1994
R746 VDD.n144 VDD.n120 11.9077
R747 VDD.n55 VDD.n31 11.9077
R748 VDD.n144 VDD.n143 11.1661
R749 VDD.n152 VDD.n151 11.1661
R750 VDD.n160 VDD.n159 11.1661
R751 VDD.n168 VDD.n167 11.1661
R752 VDD.n172 VDD.n171 11.1661
R753 VDD.n176 VDD.n175 11.1661
R754 VDD.n55 VDD.n54 11.1661
R755 VDD.n63 VDD.n62 11.1661
R756 VDD.n71 VDD.n70 11.1661
R757 VDD.n79 VDD.n78 11.1661
R758 VDD.n83 VDD.n82 11.1661
R759 VDD.n87 VDD.n86 11.1661
R760 VDD.n92 VDD.n90 5.51014
R761 VDD.n123 VDD.n121 5.51014
R762 VDD.n147 VDD.n145 5.51014
R763 VDD.n155 VDD.n153 5.51014
R764 VDD.n163 VDD.n161 5.51014
R765 VDD.n171 VDD.n169 5.51014
R766 VDD.n175 VDD.n173 5.51014
R767 VDD.n3 VDD.n1 5.51014
R768 VDD.n34 VDD.n32 5.51014
R769 VDD.n58 VDD.n56 5.51014
R770 VDD.n66 VDD.n64 5.51014
R771 VDD.n74 VDD.n72 5.51014
R772 VDD.n82 VDD.n80 5.51014
R773 VDD.n86 VDD.n84 5.51014
R774 VDD.n120 VDD.n119 5.32067
R775 VDD.n118 VDD.n117 5.32067
R776 VDD.n116 VDD.n115 5.32067
R777 VDD.n114 VDD.n113 5.32067
R778 VDD.n112 VDD.n111 5.32067
R779 VDD.n110 VDD.n109 5.32067
R780 VDD.n108 VDD.n107 5.32067
R781 VDD.n106 VDD.n105 5.32067
R782 VDD.n104 VDD.n103 5.32067
R783 VDD.n102 VDD.n101 5.32067
R784 VDD.n100 VDD.n99 5.32067
R785 VDD.n98 VDD.n97 5.32067
R786 VDD.n96 VDD.n95 5.32067
R787 VDD.n94 VDD.n93 5.32067
R788 VDD.n92 VDD.n91 5.32067
R789 VDD.n143 VDD.n142 5.32067
R790 VDD.n141 VDD.n140 5.32067
R791 VDD.n139 VDD.n138 5.32067
R792 VDD.n137 VDD.n136 5.32067
R793 VDD.n135 VDD.n134 5.32067
R794 VDD.n133 VDD.n132 5.32067
R795 VDD.n131 VDD.n130 5.32067
R796 VDD.n129 VDD.n128 5.32067
R797 VDD.n127 VDD.n126 5.32067
R798 VDD.n125 VDD.n124 5.32067
R799 VDD.n123 VDD.n122 5.32067
R800 VDD.n151 VDD.n150 5.32067
R801 VDD.n149 VDD.n148 5.32067
R802 VDD.n147 VDD.n146 5.32067
R803 VDD.n159 VDD.n158 5.32067
R804 VDD.n157 VDD.n156 5.32067
R805 VDD.n155 VDD.n154 5.32067
R806 VDD.n167 VDD.n166 5.32067
R807 VDD.n165 VDD.n164 5.32067
R808 VDD.n163 VDD.n162 5.32067
R809 VDD.n171 VDD.n170 5.32067
R810 VDD.n175 VDD.n174 5.32067
R811 VDD.n31 VDD.n30 5.32067
R812 VDD.n29 VDD.n28 5.32067
R813 VDD.n27 VDD.n26 5.32067
R814 VDD.n25 VDD.n24 5.32067
R815 VDD.n23 VDD.n22 5.32067
R816 VDD.n21 VDD.n20 5.32067
R817 VDD.n19 VDD.n18 5.32067
R818 VDD.n17 VDD.n16 5.32067
R819 VDD.n15 VDD.n14 5.32067
R820 VDD.n13 VDD.n12 5.32067
R821 VDD.n11 VDD.n10 5.32067
R822 VDD.n9 VDD.n8 5.32067
R823 VDD.n7 VDD.n6 5.32067
R824 VDD.n5 VDD.n4 5.32067
R825 VDD.n3 VDD.n2 5.32067
R826 VDD.n54 VDD.n53 5.32067
R827 VDD.n52 VDD.n51 5.32067
R828 VDD.n50 VDD.n49 5.32067
R829 VDD.n48 VDD.n47 5.32067
R830 VDD.n46 VDD.n45 5.32067
R831 VDD.n44 VDD.n43 5.32067
R832 VDD.n42 VDD.n41 5.32067
R833 VDD.n40 VDD.n39 5.32067
R834 VDD.n38 VDD.n37 5.32067
R835 VDD.n36 VDD.n35 5.32067
R836 VDD.n34 VDD.n33 5.32067
R837 VDD.n62 VDD.n61 5.32067
R838 VDD.n60 VDD.n59 5.32067
R839 VDD.n58 VDD.n57 5.32067
R840 VDD.n70 VDD.n69 5.32067
R841 VDD.n68 VDD.n67 5.32067
R842 VDD.n66 VDD.n65 5.32067
R843 VDD.n78 VDD.n77 5.32067
R844 VDD.n76 VDD.n75 5.32067
R845 VDD.n74 VDD.n73 5.32067
R846 VDD.n82 VDD.n81 5.32067
R847 VDD.n86 VDD.n85 5.32067
R848 VDD.n89 VDD.n0 4.5005
R849 VDD.n178 VDD.n0 4.5005
R850 VDD.n89 VDD.n88 3.31749
R851 VDD.n178 VDD.n177 2.77651
R852 VDD.n180 VDD.n179 2.26839
R853 VDD VDD.n180 1.13544
R854 VDD.n152 VDD.n144 0.5981
R855 VDD.n63 VDD.n55 0.5981
R856 VDD.n172 VDD.n168 0.3101
R857 VDD.n168 VDD.n160 0.3101
R858 VDD.n160 VDD.n152 0.3101
R859 VDD.n83 VDD.n79 0.3101
R860 VDD.n79 VDD.n71 0.3101
R861 VDD.n71 VDD.n63 0.3101
R862 VDD.n177 VDD.n176 0.244205
R863 VDD.n88 VDD.n87 0.244205
R864 VDD.n176 VDD.n172 0.2381
R865 VDD.n87 VDD.n83 0.2381
R866 VDD.n119 VDD.t141 0.228
R867 VDD.n119 VDD.t171 0.228
R868 VDD.n117 VDD.t227 0.228
R869 VDD.n117 VDD.t45 0.228
R870 VDD.n115 VDD.t73 0.228
R871 VDD.n115 VDD.t5 0.228
R872 VDD.n113 VDD.t327 0.228
R873 VDD.n113 VDD.t215 0.228
R874 VDD.n111 VDD.t345 0.228
R875 VDD.n111 VDD.t239 0.228
R876 VDD.n109 VDD.t169 0.228
R877 VDD.n109 VDD.t193 0.228
R878 VDD.n107 VDD.t213 0.228
R879 VDD.n107 VDD.t225 0.228
R880 VDD.n105 VDD.t209 0.228
R881 VDD.n105 VDD.t325 0.228
R882 VDD.n103 VDD.t139 0.228
R883 VDD.n103 VDD.t207 0.228
R884 VDD.n101 VDD.t3 0.228
R885 VDD.n101 VDD.t43 0.228
R886 VDD.n99 VDD.t249 0.228
R887 VDD.n99 VDD.t71 0.228
R888 VDD.n97 VDD.t41 0.228
R889 VDD.n97 VDD.t137 0.228
R890 VDD.n95 VDD.t69 0.228
R891 VDD.n95 VDD.t1 0.228
R892 VDD.n93 VDD.t39 0.228
R893 VDD.n93 VDD.t135 0.228
R894 VDD.n91 VDD.t273 0.228
R895 VDD.n91 VDD.t253 0.228
R896 VDD.n90 VDD.t343 0.228
R897 VDD.n90 VDD.t323 0.228
R898 VDD.n142 VDD.t333 0.228
R899 VDD.n142 VDD.t219 0.228
R900 VDD.n140 VDD.t199 0.228
R901 VDD.n140 VDD.t335 0.228
R902 VDD.n138 VDD.t241 0.228
R903 VDD.n138 VDD.t201 0.228
R904 VDD.n136 VDD.t195 0.228
R905 VDD.n136 VDD.t243 0.228
R906 VDD.n134 VDD.t65 0.228
R907 VDD.n134 VDD.t197 0.228
R908 VDD.n132 VDD.t101 0.228
R909 VDD.n132 VDD.t67 0.228
R910 VDD.n130 VDD.t131 0.228
R911 VDD.n130 VDD.t103 0.228
R912 VDD.n128 VDD.t229 0.228
R913 VDD.n128 VDD.t133 0.228
R914 VDD.n126 VDD.t217 0.228
R915 VDD.n126 VDD.t21 0.228
R916 VDD.n124 VDD.t211 0.228
R917 VDD.n124 VDD.t331 0.228
R918 VDD.n122 VDD.t99 0.228
R919 VDD.n122 VDD.t63 0.228
R920 VDD.n121 VDD.t19 0.228
R921 VDD.n121 VDD.t129 0.228
R922 VDD.n150 VDD.t339 0.228
R923 VDD.n150 VDD.t337 0.228
R924 VDD.n148 VDD.t247 0.228
R925 VDD.n148 VDD.t245 0.228
R926 VDD.n146 VDD.t237 0.228
R927 VDD.n146 VDD.t235 0.228
R928 VDD.n145 VDD.t223 0.228
R929 VDD.n145 VDD.t221 0.228
R930 VDD.n158 VDD.t81 0.228
R931 VDD.n158 VDD.t79 0.228
R932 VDD.n156 VDD.t205 0.228
R933 VDD.n156 VDD.t203 0.228
R934 VDD.n154 VDD.t25 0.228
R935 VDD.n154 VDD.t23 0.228
R936 VDD.n153 VDD.t77 0.228
R937 VDD.n153 VDD.t75 0.228
R938 VDD.n166 VDD.t125 0.228
R939 VDD.n166 VDD.t127 0.228
R940 VDD.n164 VDD.t111 0.228
R941 VDD.n164 VDD.t123 0.228
R942 VDD.n162 VDD.t119 0.228
R943 VDD.n162 VDD.t121 0.228
R944 VDD.n161 VDD.t115 0.228
R945 VDD.n161 VDD.t117 0.228
R946 VDD.n170 VDD.t15 0.228
R947 VDD.n170 VDD.t17 0.228
R948 VDD.n169 VDD.t11 0.228
R949 VDD.n169 VDD.t13 0.228
R950 VDD.n174 VDD.t109 0.228
R951 VDD.n174 VDD.t113 0.228
R952 VDD.n173 VDD.t105 0.228
R953 VDD.n173 VDD.t107 0.228
R954 VDD.n30 VDD.t189 0.228
R955 VDD.n30 VDD.t95 0.228
R956 VDD.n28 VDD.t165 0.228
R957 VDD.n28 VDD.t191 0.228
R958 VDD.n26 VDD.t35 0.228
R959 VDD.n26 VDD.t167 0.228
R960 VDD.n24 VDD.t91 0.228
R961 VDD.n24 VDD.t37 0.228
R962 VDD.n22 VDD.t185 0.228
R963 VDD.n22 VDD.t93 0.228
R964 VDD.n20 VDD.t269 0.228
R965 VDD.n20 VDD.t187 0.228
R966 VDD.n18 VDD.t161 0.228
R967 VDD.n18 VDD.t271 0.228
R968 VDD.n16 VDD.t31 0.228
R969 VDD.n16 VDD.t163 0.228
R970 VDD.n14 VDD.t87 0.228
R971 VDD.n14 VDD.t33 0.228
R972 VDD.n12 VDD.t181 0.228
R973 VDD.n12 VDD.t89 0.228
R974 VDD.n10 VDD.t265 0.228
R975 VDD.n10 VDD.t183 0.228
R976 VDD.n8 VDD.t157 0.228
R977 VDD.n8 VDD.t267 0.228
R978 VDD.n6 VDD.t27 0.228
R979 VDD.n6 VDD.t159 0.228
R980 VDD.n4 VDD.t83 0.228
R981 VDD.n4 VDD.t29 0.228
R982 VDD.n2 VDD.t177 0.228
R983 VDD.n2 VDD.t85 0.228
R984 VDD.n1 VDD.t155 0.228
R985 VDD.n1 VDD.t179 0.228
R986 VDD.n53 VDD.t51 0.228
R987 VDD.n53 VDD.t145 0.228
R988 VDD.n51 VDD.t293 0.228
R989 VDD.n51 VDD.t53 0.228
R990 VDD.n49 VDD.t285 0.228
R991 VDD.n49 VDD.t295 0.228
R992 VDD.n47 VDD.t289 0.228
R993 VDD.n47 VDD.t287 0.228
R994 VDD.n45 VDD.t255 0.228
R995 VDD.n45 VDD.t291 0.228
R996 VDD.n43 VDD.t147 0.228
R997 VDD.n43 VDD.t257 0.228
R998 VDD.n41 VDD.t281 0.228
R999 VDD.n41 VDD.t149 0.228
R1000 VDD.n39 VDD.t47 0.228
R1001 VDD.n39 VDD.t283 0.228
R1002 VDD.n37 VDD.t277 0.228
R1003 VDD.n37 VDD.t49 0.228
R1004 VDD.n35 VDD.t7 0.228
R1005 VDD.n35 VDD.t279 0.228
R1006 VDD.n33 VDD.t151 0.228
R1007 VDD.n33 VDD.t9 0.228
R1008 VDD.n32 VDD.t321 0.228
R1009 VDD.n32 VDD.t153 0.228
R1010 VDD.n61 VDD.t341 0.228
R1011 VDD.n61 VDD.t173 0.228
R1012 VDD.n59 VDD.t175 0.228
R1013 VDD.n59 VDD.t97 0.228
R1014 VDD.n57 VDD.t251 0.228
R1015 VDD.n57 VDD.t329 0.228
R1016 VDD.n56 VDD.t143 0.228
R1017 VDD.n56 VDD.t275 0.228
R1018 VDD.n69 VDD.t233 0.228
R1019 VDD.n69 VDD.t351 0.228
R1020 VDD.n67 VDD.t259 0.228
R1021 VDD.n67 VDD.t347 0.228
R1022 VDD.n65 VDD.t261 0.228
R1023 VDD.n65 VDD.t263 0.228
R1024 VDD.n64 VDD.t349 0.228
R1025 VDD.n64 VDD.t231 0.228
R1026 VDD.n77 VDD.t317 0.228
R1027 VDD.n77 VDD.t319 0.228
R1028 VDD.n75 VDD.t297 0.228
R1029 VDD.n75 VDD.t315 0.228
R1030 VDD.n73 VDD.t313 0.228
R1031 VDD.n73 VDD.t307 0.228
R1032 VDD.n72 VDD.t309 0.228
R1033 VDD.n72 VDD.t311 0.228
R1034 VDD.n81 VDD.t59 0.228
R1035 VDD.n81 VDD.t61 0.228
R1036 VDD.n80 VDD.t55 0.228
R1037 VDD.n80 VDD.t57 0.228
R1038 VDD.n85 VDD.t303 0.228
R1039 VDD.n85 VDD.t305 0.228
R1040 VDD.n84 VDD.t299 0.228
R1041 VDD.n84 VDD.t301 0.228
R1042 VDD.n94 VDD.n92 0.189974
R1043 VDD.n96 VDD.n94 0.189974
R1044 VDD.n98 VDD.n96 0.189974
R1045 VDD.n100 VDD.n98 0.189974
R1046 VDD.n102 VDD.n100 0.189974
R1047 VDD.n104 VDD.n102 0.189974
R1048 VDD.n106 VDD.n104 0.189974
R1049 VDD.n108 VDD.n106 0.189974
R1050 VDD.n110 VDD.n108 0.189974
R1051 VDD.n112 VDD.n110 0.189974
R1052 VDD.n114 VDD.n112 0.189974
R1053 VDD.n116 VDD.n114 0.189974
R1054 VDD.n118 VDD.n116 0.189974
R1055 VDD.n120 VDD.n118 0.189974
R1056 VDD.n125 VDD.n123 0.189974
R1057 VDD.n127 VDD.n125 0.189974
R1058 VDD.n129 VDD.n127 0.189974
R1059 VDD.n131 VDD.n129 0.189974
R1060 VDD.n133 VDD.n131 0.189974
R1061 VDD.n135 VDD.n133 0.189974
R1062 VDD.n137 VDD.n135 0.189974
R1063 VDD.n139 VDD.n137 0.189974
R1064 VDD.n141 VDD.n139 0.189974
R1065 VDD.n143 VDD.n141 0.189974
R1066 VDD.n149 VDD.n147 0.189974
R1067 VDD.n151 VDD.n149 0.189974
R1068 VDD.n157 VDD.n155 0.189974
R1069 VDD.n159 VDD.n157 0.189974
R1070 VDD.n165 VDD.n163 0.189974
R1071 VDD.n167 VDD.n165 0.189974
R1072 VDD.n5 VDD.n3 0.189974
R1073 VDD.n7 VDD.n5 0.189974
R1074 VDD.n9 VDD.n7 0.189974
R1075 VDD.n11 VDD.n9 0.189974
R1076 VDD.n13 VDD.n11 0.189974
R1077 VDD.n15 VDD.n13 0.189974
R1078 VDD.n17 VDD.n15 0.189974
R1079 VDD.n19 VDD.n17 0.189974
R1080 VDD.n21 VDD.n19 0.189974
R1081 VDD.n23 VDD.n21 0.189974
R1082 VDD.n25 VDD.n23 0.189974
R1083 VDD.n27 VDD.n25 0.189974
R1084 VDD.n29 VDD.n27 0.189974
R1085 VDD.n31 VDD.n29 0.189974
R1086 VDD.n36 VDD.n34 0.189974
R1087 VDD.n38 VDD.n36 0.189974
R1088 VDD.n40 VDD.n38 0.189974
R1089 VDD.n42 VDD.n40 0.189974
R1090 VDD.n44 VDD.n42 0.189974
R1091 VDD.n46 VDD.n44 0.189974
R1092 VDD.n48 VDD.n46 0.189974
R1093 VDD.n50 VDD.n48 0.189974
R1094 VDD.n52 VDD.n50 0.189974
R1095 VDD.n54 VDD.n52 0.189974
R1096 VDD.n60 VDD.n58 0.189974
R1097 VDD.n62 VDD.n60 0.189974
R1098 VDD.n68 VDD.n66 0.189974
R1099 VDD.n70 VDD.n68 0.189974
R1100 VDD.n76 VDD.n74 0.189974
R1101 VDD.n78 VDD.n76 0.189974
R1102 VDD.n180 VDD.n0 0.020105
R1103 VDD.n179 VDD.n178 0.0054955
R1104 VDD.n179 VDD.n89 0.0054955
R1105 VSS.n97 VSS.n96 5121.21
R1106 VSS.n187 VSS.n97 5121.21
R1107 VSS.n94 VSS.n93 4481.41
R1108 VSS.n188 VSS.n187 4318.83
R1109 VSS.n95 VSS.n94 3545.45
R1110 VSS.n96 VSS.n95 3545.45
R1111 VSS.t302 VSS.t68 1481.56
R1112 VSS.t74 VSS.t304 1481.56
R1113 VSS.t316 VSS.t238 1481.56
R1114 VSS.t122 VSS.t66 1481.56
R1115 VSS.t24 VSS.t182 1481.56
R1116 VSS.t156 VSS.t102 1481.56
R1117 VSS.t134 VSS.t4 1481.56
R1118 VSS.t10 VSS.t124 1481.56
R1119 VSS.t146 VSS.t30 1481.56
R1120 VSS.t86 VSS.t242 1481.56
R1121 VSS.t270 VSS.t236 1481.56
R1122 VSS.t228 VSS.t224 1481.56
R1123 VSS.n4 VSS.t294 1285.47
R1124 VSS.n186 VSS.t130 1285.47
R1125 VSS.n95 VSS.n3 933.951
R1126 VSS.n96 VSS.n2 933.951
R1127 VSS.n94 VSS.n4 907.822
R1128 VSS.n187 VSS.n186 907.822
R1129 VSS.n189 VSS.n97 313.527
R1130 VSS.t294 VSS.t298 145.251
R1131 VSS.t298 VSS.t300 145.251
R1132 VSS.t300 VSS.t302 145.251
R1133 VSS.t68 VSS.t70 145.251
R1134 VSS.t70 VSS.t72 145.251
R1135 VSS.t72 VSS.t74 145.251
R1136 VSS.t304 VSS.t306 145.251
R1137 VSS.t306 VSS.t308 145.251
R1138 VSS.t308 VSS.t296 145.251
R1139 VSS.t296 VSS.t310 145.251
R1140 VSS.t310 VSS.t312 145.251
R1141 VSS.t312 VSS.t314 145.251
R1142 VSS.t314 VSS.t316 145.251
R1143 VSS.t238 VSS.t340 145.251
R1144 VSS.t340 VSS.t348 145.251
R1145 VSS.t348 VSS.t44 145.251
R1146 VSS.t44 VSS.t108 145.251
R1147 VSS.t108 VSS.t222 145.251
R1148 VSS.t222 VSS.t84 145.251
R1149 VSS.t84 VSS.t122 145.251
R1150 VSS.t66 VSS.t350 145.251
R1151 VSS.t350 VSS.t180 145.251
R1152 VSS.t180 VSS.t26 145.251
R1153 VSS.t26 VSS.t230 145.251
R1154 VSS.t230 VSS.t288 145.251
R1155 VSS.t288 VSS.t324 145.251
R1156 VSS.t324 VSS.t24 145.251
R1157 VSS.t182 VSS.t174 145.251
R1158 VSS.t174 VSS.t172 145.251
R1159 VSS.t172 VSS.t94 145.251
R1160 VSS.t94 VSS.t92 145.251
R1161 VSS.t92 VSS.t178 145.251
R1162 VSS.t178 VSS.t176 145.251
R1163 VSS.t176 VSS.t14 145.251
R1164 VSS.t14 VSS.t12 145.251
R1165 VSS.t12 VSS.t78 145.251
R1166 VSS.t78 VSS.t76 145.251
R1167 VSS.t76 VSS.t170 145.251
R1168 VSS.t170 VSS.t168 145.251
R1169 VSS.t168 VSS.t292 145.251
R1170 VSS.t292 VSS.t290 145.251
R1171 VSS.t290 VSS.t334 145.251
R1172 VSS.t334 VSS.t332 145.251
R1173 VSS.t332 VSS.t186 145.251
R1174 VSS.t186 VSS.t184 145.251
R1175 VSS.t184 VSS.t282 145.251
R1176 VSS.t282 VSS.t280 145.251
R1177 VSS.t280 VSS.t256 145.251
R1178 VSS.t256 VSS.t254 145.251
R1179 VSS.t254 VSS.t156 145.251
R1180 VSS.t102 VSS.t38 145.251
R1181 VSS.t38 VSS.t36 145.251
R1182 VSS.t36 VSS.t190 145.251
R1183 VSS.t190 VSS.t188 145.251
R1184 VSS.t188 VSS.t210 145.251
R1185 VSS.t210 VSS.t208 145.251
R1186 VSS.t208 VSS.t106 145.251
R1187 VSS.t106 VSS.t104 145.251
R1188 VSS.t104 VSS.t42 145.251
R1189 VSS.t42 VSS.t40 145.251
R1190 VSS.t40 VSS.t194 145.251
R1191 VSS.t194 VSS.t192 145.251
R1192 VSS.t192 VSS.t214 145.251
R1193 VSS.t214 VSS.t212 145.251
R1194 VSS.t212 VSS.t112 145.251
R1195 VSS.t112 VSS.t110 145.251
R1196 VSS.t110 VSS.t48 145.251
R1197 VSS.t48 VSS.t46 145.251
R1198 VSS.t46 VSS.t198 145.251
R1199 VSS.t198 VSS.t196 145.251
R1200 VSS.t196 VSS.t218 145.251
R1201 VSS.t218 VSS.t216 145.251
R1202 VSS.t216 VSS.t116 145.251
R1203 VSS.t116 VSS.t114 145.251
R1204 VSS.t114 VSS.t52 145.251
R1205 VSS.t52 VSS.t50 145.251
R1206 VSS.t50 VSS.t202 145.251
R1207 VSS.t202 VSS.t200 145.251
R1208 VSS.t200 VSS.t56 145.251
R1209 VSS.t56 VSS.t54 145.251
R1210 VSS.t54 VSS.t158 145.251
R1211 VSS.t130 VSS.t128 145.251
R1212 VSS.t128 VSS.t132 145.251
R1213 VSS.t132 VSS.t134 145.251
R1214 VSS.t4 VSS.t6 145.251
R1215 VSS.t6 VSS.t8 145.251
R1216 VSS.t8 VSS.t10 145.251
R1217 VSS.t124 VSS.t136 145.251
R1218 VSS.t136 VSS.t138 145.251
R1219 VSS.t138 VSS.t126 145.251
R1220 VSS.t126 VSS.t140 145.251
R1221 VSS.t140 VSS.t142 145.251
R1222 VSS.t142 VSS.t144 145.251
R1223 VSS.t144 VSS.t146 145.251
R1224 VSS.t30 VSS.t28 145.251
R1225 VSS.t28 VSS.t98 145.251
R1226 VSS.t98 VSS.t96 145.251
R1227 VSS.t96 VSS.t34 145.251
R1228 VSS.t34 VSS.t32 145.251
R1229 VSS.t32 VSS.t100 145.251
R1230 VSS.t100 VSS.t86 145.251
R1231 VSS.t242 VSS.t240 145.251
R1232 VSS.t240 VSS.t252 145.251
R1233 VSS.t252 VSS.t250 145.251
R1234 VSS.t250 VSS.t268 145.251
R1235 VSS.t268 VSS.t266 145.251
R1236 VSS.t266 VSS.t272 145.251
R1237 VSS.t272 VSS.t270 145.251
R1238 VSS.t236 VSS.t248 145.251
R1239 VSS.t248 VSS.t246 145.251
R1240 VSS.t246 VSS.t264 145.251
R1241 VSS.t264 VSS.t262 145.251
R1242 VSS.t262 VSS.t322 145.251
R1243 VSS.t322 VSS.t320 145.251
R1244 VSS.t320 VSS.t18 145.251
R1245 VSS.t18 VSS.t16 145.251
R1246 VSS.t16 VSS.t150 145.251
R1247 VSS.t150 VSS.t148 145.251
R1248 VSS.t148 VSS.t338 145.251
R1249 VSS.t338 VSS.t336 145.251
R1250 VSS.t336 VSS.t286 145.251
R1251 VSS.t286 VSS.t284 145.251
R1252 VSS.t284 VSS.t22 145.251
R1253 VSS.t22 VSS.t20 145.251
R1254 VSS.t20 VSS.t154 145.251
R1255 VSS.t154 VSS.t152 145.251
R1256 VSS.t152 VSS.t120 145.251
R1257 VSS.t120 VSS.t118 145.251
R1258 VSS.t118 VSS.t82 145.251
R1259 VSS.t82 VSS.t80 145.251
R1260 VSS.t80 VSS.t228 145.251
R1261 VSS.t224 VSS.t344 145.251
R1262 VSS.t344 VSS.t258 145.251
R1263 VSS.t258 VSS.t318 145.251
R1264 VSS.t318 VSS.t58 145.251
R1265 VSS.t58 VSS.t160 145.251
R1266 VSS.t160 VSS.t204 145.251
R1267 VSS.t204 VSS.t346 145.251
R1268 VSS.t346 VSS.t326 145.251
R1269 VSS.t326 VSS.t206 145.251
R1270 VSS.t206 VSS.t278 145.251
R1271 VSS.t278 VSS.t274 145.251
R1272 VSS.t274 VSS.t60 145.251
R1273 VSS.t60 VSS.t162 145.251
R1274 VSS.t162 VSS.t88 145.251
R1275 VSS.t88 VSS.t0 145.251
R1276 VSS.t0 VSS.t62 145.251
R1277 VSS.t62 VSS.t164 145.251
R1278 VSS.t164 VSS.t276 145.251
R1279 VSS.t276 VSS.t90 145.251
R1280 VSS.t90 VSS.t2 145.251
R1281 VSS.t2 VSS.t64 145.251
R1282 VSS.t64 VSS.t166 145.251
R1283 VSS.t166 VSS.t226 145.251
R1284 VSS.t226 VSS.t232 145.251
R1285 VSS.t232 VSS.t328 145.251
R1286 VSS.t328 VSS.t234 145.251
R1287 VSS.t234 VSS.t244 145.251
R1288 VSS.t244 VSS.t220 145.251
R1289 VSS.t220 VSS.t342 145.251
R1290 VSS.t342 VSS.t260 145.251
R1291 VSS.t260 VSS.t330 145.251
R1292 VSS.n92 VSS.n4 24.2224
R1293 VSS.n186 VSS.n185 24.2224
R1294 VSS.n59 VSS.n35 10.7184
R1295 VSS.n152 VSS.n128 10.7184
R1296 VSS.n59 VSS.n58 9.9768
R1297 VSS.n67 VSS.n66 9.9768
R1298 VSS.n75 VSS.n74 9.9768
R1299 VSS.n83 VSS.n82 9.9768
R1300 VSS.n87 VSS.n86 9.9768
R1301 VSS.n91 VSS.n90 9.9768
R1302 VSS.n152 VSS.n151 9.9768
R1303 VSS.n160 VSS.n159 9.9768
R1304 VSS.n168 VSS.n167 9.9768
R1305 VSS.n176 VSS.n175 9.9768
R1306 VSS.n180 VSS.n179 9.9768
R1307 VSS.n184 VSS.n183 9.9768
R1308 VSS.n7 VSS.n5 5.57485
R1309 VSS.n38 VSS.n36 5.57485
R1310 VSS.n62 VSS.n60 5.57485
R1311 VSS.n70 VSS.n68 5.57485
R1312 VSS.n78 VSS.n76 5.57485
R1313 VSS.n86 VSS.n84 5.57485
R1314 VSS.n90 VSS.n88 5.57485
R1315 VSS.n100 VSS.n98 5.57485
R1316 VSS.n131 VSS.n129 5.57485
R1317 VSS.n155 VSS.n153 5.57485
R1318 VSS.n163 VSS.n161 5.57485
R1319 VSS.n171 VSS.n169 5.57485
R1320 VSS.n179 VSS.n177 5.57485
R1321 VSS.n183 VSS.n181 5.57485
R1322 VSS.n35 VSS.n34 5.38537
R1323 VSS.n33 VSS.n32 5.38537
R1324 VSS.n31 VSS.n30 5.38537
R1325 VSS.n29 VSS.n28 5.38537
R1326 VSS.n27 VSS.n26 5.38537
R1327 VSS.n25 VSS.n24 5.38537
R1328 VSS.n23 VSS.n22 5.38537
R1329 VSS.n21 VSS.n20 5.38537
R1330 VSS.n19 VSS.n18 5.38537
R1331 VSS.n17 VSS.n16 5.38537
R1332 VSS.n15 VSS.n14 5.38537
R1333 VSS.n13 VSS.n12 5.38537
R1334 VSS.n11 VSS.n10 5.38537
R1335 VSS.n9 VSS.n8 5.38537
R1336 VSS.n7 VSS.n6 5.38537
R1337 VSS.n58 VSS.n57 5.38537
R1338 VSS.n56 VSS.n55 5.38537
R1339 VSS.n54 VSS.n53 5.38537
R1340 VSS.n52 VSS.n51 5.38537
R1341 VSS.n50 VSS.n49 5.38537
R1342 VSS.n48 VSS.n47 5.38537
R1343 VSS.n46 VSS.n45 5.38537
R1344 VSS.n44 VSS.n43 5.38537
R1345 VSS.n42 VSS.n41 5.38537
R1346 VSS.n40 VSS.n39 5.38537
R1347 VSS.n38 VSS.n37 5.38537
R1348 VSS.n66 VSS.n65 5.38537
R1349 VSS.n64 VSS.n63 5.38537
R1350 VSS.n62 VSS.n61 5.38537
R1351 VSS.n74 VSS.n73 5.38537
R1352 VSS.n72 VSS.n71 5.38537
R1353 VSS.n70 VSS.n69 5.38537
R1354 VSS.n82 VSS.n81 5.38537
R1355 VSS.n80 VSS.n79 5.38537
R1356 VSS.n78 VSS.n77 5.38537
R1357 VSS.n86 VSS.n85 5.38537
R1358 VSS.n90 VSS.n89 5.38537
R1359 VSS.n128 VSS.n127 5.38537
R1360 VSS.n126 VSS.n125 5.38537
R1361 VSS.n124 VSS.n123 5.38537
R1362 VSS.n122 VSS.n121 5.38537
R1363 VSS.n120 VSS.n119 5.38537
R1364 VSS.n118 VSS.n117 5.38537
R1365 VSS.n116 VSS.n115 5.38537
R1366 VSS.n114 VSS.n113 5.38537
R1367 VSS.n112 VSS.n111 5.38537
R1368 VSS.n110 VSS.n109 5.38537
R1369 VSS.n108 VSS.n107 5.38537
R1370 VSS.n106 VSS.n105 5.38537
R1371 VSS.n104 VSS.n103 5.38537
R1372 VSS.n102 VSS.n101 5.38537
R1373 VSS.n100 VSS.n99 5.38537
R1374 VSS.n151 VSS.n150 5.38537
R1375 VSS.n149 VSS.n148 5.38537
R1376 VSS.n147 VSS.n146 5.38537
R1377 VSS.n145 VSS.n144 5.38537
R1378 VSS.n143 VSS.n142 5.38537
R1379 VSS.n141 VSS.n140 5.38537
R1380 VSS.n139 VSS.n138 5.38537
R1381 VSS.n137 VSS.n136 5.38537
R1382 VSS.n135 VSS.n134 5.38537
R1383 VSS.n133 VSS.n132 5.38537
R1384 VSS.n131 VSS.n130 5.38537
R1385 VSS.n159 VSS.n158 5.38537
R1386 VSS.n157 VSS.n156 5.38537
R1387 VSS.n155 VSS.n154 5.38537
R1388 VSS.n167 VSS.n166 5.38537
R1389 VSS.n165 VSS.n164 5.38537
R1390 VSS.n163 VSS.n162 5.38537
R1391 VSS.n175 VSS.n174 5.38537
R1392 VSS.n173 VSS.n172 5.38537
R1393 VSS.n171 VSS.n170 5.38537
R1394 VSS.n179 VSS.n178 5.38537
R1395 VSS.n183 VSS.n182 5.38537
R1396 VSS.n1 VSS.n0 4.5005
R1397 VSS.n190 VSS.n0 4.5005
R1398 VSS.n192 VSS.n191 2.26839
R1399 VSS.n93 VSS.n92 1.90847
R1400 VSS.n188 VSS.n185 1.90847
R1401 VSS VSS.n192 1.13544
R1402 VSS.n67 VSS.n59 0.5981
R1403 VSS.n160 VSS.n152 0.5981
R1404 VSS.n93 VSS.n3 0.543479
R1405 VSS.n3 VSS.n2 0.543479
R1406 VSS.n189 VSS.n188 0.543479
R1407 VSS.n2 VSS.n1 0.507615
R1408 VSS.n190 VSS.n189 0.507363
R1409 VSS.n87 VSS.n83 0.3101
R1410 VSS.n83 VSS.n75 0.3101
R1411 VSS.n75 VSS.n67 0.3101
R1412 VSS.n180 VSS.n176 0.3101
R1413 VSS.n176 VSS.n168 0.3101
R1414 VSS.n168 VSS.n160 0.3101
R1415 VSS.n92 VSS.n91 0.244205
R1416 VSS.n185 VSS.n184 0.244205
R1417 VSS.n91 VSS.n87 0.2381
R1418 VSS.n184 VSS.n180 0.2381
R1419 VSS.n34 VSS.t55 0.20525
R1420 VSS.n34 VSS.t159 0.20525
R1421 VSS.n32 VSS.t201 0.20525
R1422 VSS.n32 VSS.t57 0.20525
R1423 VSS.n30 VSS.t51 0.20525
R1424 VSS.n30 VSS.t203 0.20525
R1425 VSS.n28 VSS.t115 0.20525
R1426 VSS.n28 VSS.t53 0.20525
R1427 VSS.n26 VSS.t217 0.20525
R1428 VSS.n26 VSS.t117 0.20525
R1429 VSS.n24 VSS.t197 0.20525
R1430 VSS.n24 VSS.t219 0.20525
R1431 VSS.n22 VSS.t47 0.20525
R1432 VSS.n22 VSS.t199 0.20525
R1433 VSS.n20 VSS.t111 0.20525
R1434 VSS.n20 VSS.t49 0.20525
R1435 VSS.n18 VSS.t213 0.20525
R1436 VSS.n18 VSS.t113 0.20525
R1437 VSS.n16 VSS.t193 0.20525
R1438 VSS.n16 VSS.t215 0.20525
R1439 VSS.n14 VSS.t41 0.20525
R1440 VSS.n14 VSS.t195 0.20525
R1441 VSS.n12 VSS.t105 0.20525
R1442 VSS.n12 VSS.t43 0.20525
R1443 VSS.n10 VSS.t209 0.20525
R1444 VSS.n10 VSS.t107 0.20525
R1445 VSS.n8 VSS.t189 0.20525
R1446 VSS.n8 VSS.t211 0.20525
R1447 VSS.n6 VSS.t37 0.20525
R1448 VSS.n6 VSS.t191 0.20525
R1449 VSS.n5 VSS.t103 0.20525
R1450 VSS.n5 VSS.t39 0.20525
R1451 VSS.n57 VSS.t255 0.20525
R1452 VSS.n57 VSS.t157 0.20525
R1453 VSS.n55 VSS.t281 0.20525
R1454 VSS.n55 VSS.t257 0.20525
R1455 VSS.n53 VSS.t185 0.20525
R1456 VSS.n53 VSS.t283 0.20525
R1457 VSS.n51 VSS.t333 0.20525
R1458 VSS.n51 VSS.t187 0.20525
R1459 VSS.n49 VSS.t291 0.20525
R1460 VSS.n49 VSS.t335 0.20525
R1461 VSS.n47 VSS.t169 0.20525
R1462 VSS.n47 VSS.t293 0.20525
R1463 VSS.n45 VSS.t77 0.20525
R1464 VSS.n45 VSS.t171 0.20525
R1465 VSS.n43 VSS.t13 0.20525
R1466 VSS.n43 VSS.t79 0.20525
R1467 VSS.n41 VSS.t177 0.20525
R1468 VSS.n41 VSS.t15 0.20525
R1469 VSS.n39 VSS.t93 0.20525
R1470 VSS.n39 VSS.t179 0.20525
R1471 VSS.n37 VSS.t173 0.20525
R1472 VSS.n37 VSS.t95 0.20525
R1473 VSS.n36 VSS.t183 0.20525
R1474 VSS.n36 VSS.t175 0.20525
R1475 VSS.n65 VSS.t325 0.20525
R1476 VSS.n65 VSS.t25 0.20525
R1477 VSS.n63 VSS.t231 0.20525
R1478 VSS.n63 VSS.t289 0.20525
R1479 VSS.n61 VSS.t181 0.20525
R1480 VSS.n61 VSS.t27 0.20525
R1481 VSS.n60 VSS.t67 0.20525
R1482 VSS.n60 VSS.t351 0.20525
R1483 VSS.n73 VSS.t85 0.20525
R1484 VSS.n73 VSS.t123 0.20525
R1485 VSS.n71 VSS.t109 0.20525
R1486 VSS.n71 VSS.t223 0.20525
R1487 VSS.n69 VSS.t349 0.20525
R1488 VSS.n69 VSS.t45 0.20525
R1489 VSS.n68 VSS.t239 0.20525
R1490 VSS.n68 VSS.t341 0.20525
R1491 VSS.n81 VSS.t315 0.20525
R1492 VSS.n81 VSS.t317 0.20525
R1493 VSS.n79 VSS.t311 0.20525
R1494 VSS.n79 VSS.t313 0.20525
R1495 VSS.n77 VSS.t309 0.20525
R1496 VSS.n77 VSS.t297 0.20525
R1497 VSS.n76 VSS.t305 0.20525
R1498 VSS.n76 VSS.t307 0.20525
R1499 VSS.n85 VSS.t73 0.20525
R1500 VSS.n85 VSS.t75 0.20525
R1501 VSS.n84 VSS.t69 0.20525
R1502 VSS.n84 VSS.t71 0.20525
R1503 VSS.n89 VSS.t301 0.20525
R1504 VSS.n89 VSS.t303 0.20525
R1505 VSS.n88 VSS.t295 0.20525
R1506 VSS.n88 VSS.t299 0.20525
R1507 VSS.n127 VSS.t261 0.20525
R1508 VSS.n127 VSS.t331 0.20525
R1509 VSS.n125 VSS.t221 0.20525
R1510 VSS.n125 VSS.t343 0.20525
R1511 VSS.n123 VSS.t235 0.20525
R1512 VSS.n123 VSS.t245 0.20525
R1513 VSS.n121 VSS.t233 0.20525
R1514 VSS.n121 VSS.t329 0.20525
R1515 VSS.n119 VSS.t167 0.20525
R1516 VSS.n119 VSS.t227 0.20525
R1517 VSS.n117 VSS.t3 0.20525
R1518 VSS.n117 VSS.t65 0.20525
R1519 VSS.n115 VSS.t277 0.20525
R1520 VSS.n115 VSS.t91 0.20525
R1521 VSS.n113 VSS.t63 0.20525
R1522 VSS.n113 VSS.t165 0.20525
R1523 VSS.n111 VSS.t89 0.20525
R1524 VSS.n111 VSS.t1 0.20525
R1525 VSS.n109 VSS.t61 0.20525
R1526 VSS.n109 VSS.t163 0.20525
R1527 VSS.n107 VSS.t279 0.20525
R1528 VSS.n107 VSS.t275 0.20525
R1529 VSS.n105 VSS.t327 0.20525
R1530 VSS.n105 VSS.t207 0.20525
R1531 VSS.n103 VSS.t205 0.20525
R1532 VSS.n103 VSS.t347 0.20525
R1533 VSS.n101 VSS.t59 0.20525
R1534 VSS.n101 VSS.t161 0.20525
R1535 VSS.n99 VSS.t259 0.20525
R1536 VSS.n99 VSS.t319 0.20525
R1537 VSS.n98 VSS.t225 0.20525
R1538 VSS.n98 VSS.t345 0.20525
R1539 VSS.n150 VSS.t81 0.20525
R1540 VSS.n150 VSS.t229 0.20525
R1541 VSS.n148 VSS.t119 0.20525
R1542 VSS.n148 VSS.t83 0.20525
R1543 VSS.n146 VSS.t153 0.20525
R1544 VSS.n146 VSS.t121 0.20525
R1545 VSS.n144 VSS.t21 0.20525
R1546 VSS.n144 VSS.t155 0.20525
R1547 VSS.n142 VSS.t285 0.20525
R1548 VSS.n142 VSS.t23 0.20525
R1549 VSS.n140 VSS.t337 0.20525
R1550 VSS.n140 VSS.t287 0.20525
R1551 VSS.n138 VSS.t149 0.20525
R1552 VSS.n138 VSS.t339 0.20525
R1553 VSS.n136 VSS.t17 0.20525
R1554 VSS.n136 VSS.t151 0.20525
R1555 VSS.n134 VSS.t321 0.20525
R1556 VSS.n134 VSS.t19 0.20525
R1557 VSS.n132 VSS.t263 0.20525
R1558 VSS.n132 VSS.t323 0.20525
R1559 VSS.n130 VSS.t247 0.20525
R1560 VSS.n130 VSS.t265 0.20525
R1561 VSS.n129 VSS.t237 0.20525
R1562 VSS.n129 VSS.t249 0.20525
R1563 VSS.n158 VSS.t273 0.20525
R1564 VSS.n158 VSS.t271 0.20525
R1565 VSS.n156 VSS.t269 0.20525
R1566 VSS.n156 VSS.t267 0.20525
R1567 VSS.n154 VSS.t253 0.20525
R1568 VSS.n154 VSS.t251 0.20525
R1569 VSS.n153 VSS.t243 0.20525
R1570 VSS.n153 VSS.t241 0.20525
R1571 VSS.n166 VSS.t101 0.20525
R1572 VSS.n166 VSS.t87 0.20525
R1573 VSS.n164 VSS.t35 0.20525
R1574 VSS.n164 VSS.t33 0.20525
R1575 VSS.n162 VSS.t99 0.20525
R1576 VSS.n162 VSS.t97 0.20525
R1577 VSS.n161 VSS.t31 0.20525
R1578 VSS.n161 VSS.t29 0.20525
R1579 VSS.n174 VSS.t145 0.20525
R1580 VSS.n174 VSS.t147 0.20525
R1581 VSS.n172 VSS.t141 0.20525
R1582 VSS.n172 VSS.t143 0.20525
R1583 VSS.n170 VSS.t139 0.20525
R1584 VSS.n170 VSS.t127 0.20525
R1585 VSS.n169 VSS.t125 0.20525
R1586 VSS.n169 VSS.t137 0.20525
R1587 VSS.n178 VSS.t9 0.20525
R1588 VSS.n178 VSS.t11 0.20525
R1589 VSS.n177 VSS.t5 0.20525
R1590 VSS.n177 VSS.t7 0.20525
R1591 VSS.n182 VSS.t133 0.20525
R1592 VSS.n182 VSS.t135 0.20525
R1593 VSS.n181 VSS.t131 0.20525
R1594 VSS.n181 VSS.t129 0.20525
R1595 VSS.n9 VSS.n7 0.189974
R1596 VSS.n11 VSS.n9 0.189974
R1597 VSS.n13 VSS.n11 0.189974
R1598 VSS.n15 VSS.n13 0.189974
R1599 VSS.n17 VSS.n15 0.189974
R1600 VSS.n19 VSS.n17 0.189974
R1601 VSS.n21 VSS.n19 0.189974
R1602 VSS.n23 VSS.n21 0.189974
R1603 VSS.n25 VSS.n23 0.189974
R1604 VSS.n27 VSS.n25 0.189974
R1605 VSS.n29 VSS.n27 0.189974
R1606 VSS.n31 VSS.n29 0.189974
R1607 VSS.n33 VSS.n31 0.189974
R1608 VSS.n35 VSS.n33 0.189974
R1609 VSS.n40 VSS.n38 0.189974
R1610 VSS.n42 VSS.n40 0.189974
R1611 VSS.n44 VSS.n42 0.189974
R1612 VSS.n46 VSS.n44 0.189974
R1613 VSS.n48 VSS.n46 0.189974
R1614 VSS.n50 VSS.n48 0.189974
R1615 VSS.n52 VSS.n50 0.189974
R1616 VSS.n54 VSS.n52 0.189974
R1617 VSS.n56 VSS.n54 0.189974
R1618 VSS.n58 VSS.n56 0.189974
R1619 VSS.n64 VSS.n62 0.189974
R1620 VSS.n66 VSS.n64 0.189974
R1621 VSS.n72 VSS.n70 0.189974
R1622 VSS.n74 VSS.n72 0.189974
R1623 VSS.n80 VSS.n78 0.189974
R1624 VSS.n82 VSS.n80 0.189974
R1625 VSS.n102 VSS.n100 0.189974
R1626 VSS.n104 VSS.n102 0.189974
R1627 VSS.n106 VSS.n104 0.189974
R1628 VSS.n108 VSS.n106 0.189974
R1629 VSS.n110 VSS.n108 0.189974
R1630 VSS.n112 VSS.n110 0.189974
R1631 VSS.n114 VSS.n112 0.189974
R1632 VSS.n116 VSS.n114 0.189974
R1633 VSS.n118 VSS.n116 0.189974
R1634 VSS.n120 VSS.n118 0.189974
R1635 VSS.n122 VSS.n120 0.189974
R1636 VSS.n124 VSS.n122 0.189974
R1637 VSS.n126 VSS.n124 0.189974
R1638 VSS.n128 VSS.n126 0.189974
R1639 VSS.n133 VSS.n131 0.189974
R1640 VSS.n135 VSS.n133 0.189974
R1641 VSS.n137 VSS.n135 0.189974
R1642 VSS.n139 VSS.n137 0.189974
R1643 VSS.n141 VSS.n139 0.189974
R1644 VSS.n143 VSS.n141 0.189974
R1645 VSS.n145 VSS.n143 0.189974
R1646 VSS.n147 VSS.n145 0.189974
R1647 VSS.n149 VSS.n147 0.189974
R1648 VSS.n151 VSS.n149 0.189974
R1649 VSS.n157 VSS.n155 0.189974
R1650 VSS.n159 VSS.n157 0.189974
R1651 VSS.n165 VSS.n163 0.189974
R1652 VSS.n167 VSS.n165 0.189974
R1653 VSS.n173 VSS.n171 0.189974
R1654 VSS.n175 VSS.n173 0.189974
R1655 VSS.n192 VSS.n0 0.020105
R1656 VSS.n191 VSS.n190 0.0054955
R1657 VSS.n191 VSS.n1 0.0054955
R1658 a_15180_6400.n93 a_15180_6400.t79 113.632
R1659 a_15180_6400.n115 a_15180_6400.t48 113.632
R1660 a_15180_6400.n32 a_15180_6400.t111 113.632
R1661 a_15180_6400.n54 a_15180_6400.t80 113.632
R1662 a_15180_6400.n136 a_15180_6400.t63 109.174
R1663 a_15180_6400.n137 a_15180_6400.t64 109.174
R1664 a_15180_6400.n94 a_15180_6400.t78 109.174
R1665 a_15180_6400.n95 a_15180_6400.t77 109.174
R1666 a_15180_6400.n96 a_15180_6400.t76 109.174
R1667 a_15180_6400.n97 a_15180_6400.t75 109.174
R1668 a_15180_6400.n98 a_15180_6400.t74 109.174
R1669 a_15180_6400.n99 a_15180_6400.t73 109.174
R1670 a_15180_6400.n100 a_15180_6400.t72 109.174
R1671 a_15180_6400.n101 a_15180_6400.t71 109.174
R1672 a_15180_6400.n102 a_15180_6400.t70 109.174
R1673 a_15180_6400.n103 a_15180_6400.t69 109.174
R1674 a_15180_6400.n104 a_15180_6400.t68 109.174
R1675 a_15180_6400.n105 a_15180_6400.t67 109.174
R1676 a_15180_6400.n106 a_15180_6400.t66 109.174
R1677 a_15180_6400.n107 a_15180_6400.t65 109.174
R1678 a_15180_6400.n135 a_15180_6400.t62 109.174
R1679 a_15180_6400.n108 a_15180_6400.t61 109.174
R1680 a_15180_6400.n131 a_15180_6400.t60 109.174
R1681 a_15180_6400.n130 a_15180_6400.t59 109.174
R1682 a_15180_6400.n129 a_15180_6400.t58 109.174
R1683 a_15180_6400.n110 a_15180_6400.t57 109.174
R1684 a_15180_6400.n125 a_15180_6400.t56 109.174
R1685 a_15180_6400.n124 a_15180_6400.t55 109.174
R1686 a_15180_6400.n123 a_15180_6400.t54 109.174
R1687 a_15180_6400.n112 a_15180_6400.t53 109.174
R1688 a_15180_6400.n119 a_15180_6400.t52 109.174
R1689 a_15180_6400.n118 a_15180_6400.t51 109.174
R1690 a_15180_6400.n117 a_15180_6400.t50 109.174
R1691 a_15180_6400.n114 a_15180_6400.t49 109.174
R1692 a_15180_6400.n75 a_15180_6400.t95 109.174
R1693 a_15180_6400.n76 a_15180_6400.t96 109.174
R1694 a_15180_6400.n33 a_15180_6400.t110 109.174
R1695 a_15180_6400.n34 a_15180_6400.t109 109.174
R1696 a_15180_6400.n35 a_15180_6400.t108 109.174
R1697 a_15180_6400.n36 a_15180_6400.t107 109.174
R1698 a_15180_6400.n37 a_15180_6400.t106 109.174
R1699 a_15180_6400.n38 a_15180_6400.t105 109.174
R1700 a_15180_6400.n39 a_15180_6400.t104 109.174
R1701 a_15180_6400.n40 a_15180_6400.t103 109.174
R1702 a_15180_6400.n41 a_15180_6400.t102 109.174
R1703 a_15180_6400.n42 a_15180_6400.t101 109.174
R1704 a_15180_6400.n43 a_15180_6400.t100 109.174
R1705 a_15180_6400.n44 a_15180_6400.t99 109.174
R1706 a_15180_6400.n45 a_15180_6400.t98 109.174
R1707 a_15180_6400.n46 a_15180_6400.t97 109.174
R1708 a_15180_6400.n74 a_15180_6400.t94 109.174
R1709 a_15180_6400.n47 a_15180_6400.t93 109.174
R1710 a_15180_6400.n70 a_15180_6400.t92 109.174
R1711 a_15180_6400.n69 a_15180_6400.t91 109.174
R1712 a_15180_6400.n68 a_15180_6400.t90 109.174
R1713 a_15180_6400.n49 a_15180_6400.t89 109.174
R1714 a_15180_6400.n64 a_15180_6400.t88 109.174
R1715 a_15180_6400.n63 a_15180_6400.t87 109.174
R1716 a_15180_6400.n62 a_15180_6400.t86 109.174
R1717 a_15180_6400.n51 a_15180_6400.t85 109.174
R1718 a_15180_6400.n58 a_15180_6400.t84 109.174
R1719 a_15180_6400.n57 a_15180_6400.t83 109.174
R1720 a_15180_6400.n56 a_15180_6400.t82 109.174
R1721 a_15180_6400.n53 a_15180_6400.t81 109.174
R1722 a_15180_6400.n136 a_15180_6400.n79 18.4942
R1723 a_15180_6400.n138 a_15180_6400.n137 18.4942
R1724 a_15180_6400.n95 a_15180_6400.n92 18.4942
R1725 a_15180_6400.n96 a_15180_6400.n91 18.4942
R1726 a_15180_6400.n97 a_15180_6400.n90 18.4942
R1727 a_15180_6400.n98 a_15180_6400.n89 18.4942
R1728 a_15180_6400.n99 a_15180_6400.n88 18.4942
R1729 a_15180_6400.n100 a_15180_6400.n87 18.4942
R1730 a_15180_6400.n101 a_15180_6400.n86 18.4942
R1731 a_15180_6400.n102 a_15180_6400.n85 18.4942
R1732 a_15180_6400.n103 a_15180_6400.n84 18.4942
R1733 a_15180_6400.n104 a_15180_6400.n83 18.4942
R1734 a_15180_6400.n105 a_15180_6400.n82 18.4942
R1735 a_15180_6400.n106 a_15180_6400.n81 18.4942
R1736 a_15180_6400.n107 a_15180_6400.n80 18.4942
R1737 a_15180_6400.n135 a_15180_6400.n134 18.4942
R1738 a_15180_6400.n133 a_15180_6400.n108 18.4942
R1739 a_15180_6400.n132 a_15180_6400.n131 18.4942
R1740 a_15180_6400.n130 a_15180_6400.n109 18.4942
R1741 a_15180_6400.n129 a_15180_6400.n128 18.4942
R1742 a_15180_6400.n127 a_15180_6400.n110 18.4942
R1743 a_15180_6400.n126 a_15180_6400.n125 18.4942
R1744 a_15180_6400.n124 a_15180_6400.n111 18.4942
R1745 a_15180_6400.n123 a_15180_6400.n122 18.4942
R1746 a_15180_6400.n121 a_15180_6400.n112 18.4942
R1747 a_15180_6400.n120 a_15180_6400.n119 18.4942
R1748 a_15180_6400.n118 a_15180_6400.n113 18.4942
R1749 a_15180_6400.n117 a_15180_6400.n116 18.4942
R1750 a_15180_6400.n75 a_15180_6400.n18 18.4942
R1751 a_15180_6400.n77 a_15180_6400.n76 18.4942
R1752 a_15180_6400.n34 a_15180_6400.n31 18.4942
R1753 a_15180_6400.n35 a_15180_6400.n30 18.4942
R1754 a_15180_6400.n36 a_15180_6400.n29 18.4942
R1755 a_15180_6400.n37 a_15180_6400.n28 18.4942
R1756 a_15180_6400.n38 a_15180_6400.n27 18.4942
R1757 a_15180_6400.n39 a_15180_6400.n26 18.4942
R1758 a_15180_6400.n40 a_15180_6400.n25 18.4942
R1759 a_15180_6400.n41 a_15180_6400.n24 18.4942
R1760 a_15180_6400.n42 a_15180_6400.n23 18.4942
R1761 a_15180_6400.n43 a_15180_6400.n22 18.4942
R1762 a_15180_6400.n44 a_15180_6400.n21 18.4942
R1763 a_15180_6400.n45 a_15180_6400.n20 18.4942
R1764 a_15180_6400.n46 a_15180_6400.n19 18.4942
R1765 a_15180_6400.n74 a_15180_6400.n73 18.4942
R1766 a_15180_6400.n72 a_15180_6400.n47 18.4942
R1767 a_15180_6400.n71 a_15180_6400.n70 18.4942
R1768 a_15180_6400.n69 a_15180_6400.n48 18.4942
R1769 a_15180_6400.n68 a_15180_6400.n67 18.4942
R1770 a_15180_6400.n66 a_15180_6400.n49 18.4942
R1771 a_15180_6400.n65 a_15180_6400.n64 18.4942
R1772 a_15180_6400.n63 a_15180_6400.n50 18.4942
R1773 a_15180_6400.n62 a_15180_6400.n61 18.4942
R1774 a_15180_6400.n60 a_15180_6400.n51 18.4942
R1775 a_15180_6400.n59 a_15180_6400.n58 18.4942
R1776 a_15180_6400.n57 a_15180_6400.n52 18.4942
R1777 a_15180_6400.n56 a_15180_6400.n55 18.4942
R1778 a_15180_6400.n164 a_15180_6400.n140 17.8923
R1779 a_15180_6400.n136 a_15180_6400.n135 11.6805
R1780 a_15180_6400.n137 a_15180_6400.n136 11.6805
R1781 a_15180_6400.n95 a_15180_6400.n94 11.6805
R1782 a_15180_6400.n96 a_15180_6400.n95 11.6805
R1783 a_15180_6400.n97 a_15180_6400.n96 11.6805
R1784 a_15180_6400.n98 a_15180_6400.n97 11.6805
R1785 a_15180_6400.n99 a_15180_6400.n98 11.6805
R1786 a_15180_6400.n100 a_15180_6400.n99 11.6805
R1787 a_15180_6400.n101 a_15180_6400.n100 11.6805
R1788 a_15180_6400.n102 a_15180_6400.n101 11.6805
R1789 a_15180_6400.n103 a_15180_6400.n102 11.6805
R1790 a_15180_6400.n104 a_15180_6400.n103 11.6805
R1791 a_15180_6400.n105 a_15180_6400.n104 11.6805
R1792 a_15180_6400.n106 a_15180_6400.n105 11.6805
R1793 a_15180_6400.n107 a_15180_6400.n106 11.6805
R1794 a_15180_6400.n137 a_15180_6400.n107 11.6805
R1795 a_15180_6400.n135 a_15180_6400.n108 11.6805
R1796 a_15180_6400.n131 a_15180_6400.n108 11.6805
R1797 a_15180_6400.n131 a_15180_6400.n130 11.6805
R1798 a_15180_6400.n130 a_15180_6400.n129 11.6805
R1799 a_15180_6400.n129 a_15180_6400.n110 11.6805
R1800 a_15180_6400.n125 a_15180_6400.n110 11.6805
R1801 a_15180_6400.n125 a_15180_6400.n124 11.6805
R1802 a_15180_6400.n124 a_15180_6400.n123 11.6805
R1803 a_15180_6400.n123 a_15180_6400.n112 11.6805
R1804 a_15180_6400.n119 a_15180_6400.n112 11.6805
R1805 a_15180_6400.n119 a_15180_6400.n118 11.6805
R1806 a_15180_6400.n118 a_15180_6400.n117 11.6805
R1807 a_15180_6400.n117 a_15180_6400.n114 11.6805
R1808 a_15180_6400.n75 a_15180_6400.n74 11.6805
R1809 a_15180_6400.n76 a_15180_6400.n75 11.6805
R1810 a_15180_6400.n34 a_15180_6400.n33 11.6805
R1811 a_15180_6400.n35 a_15180_6400.n34 11.6805
R1812 a_15180_6400.n36 a_15180_6400.n35 11.6805
R1813 a_15180_6400.n37 a_15180_6400.n36 11.6805
R1814 a_15180_6400.n38 a_15180_6400.n37 11.6805
R1815 a_15180_6400.n39 a_15180_6400.n38 11.6805
R1816 a_15180_6400.n40 a_15180_6400.n39 11.6805
R1817 a_15180_6400.n41 a_15180_6400.n40 11.6805
R1818 a_15180_6400.n42 a_15180_6400.n41 11.6805
R1819 a_15180_6400.n43 a_15180_6400.n42 11.6805
R1820 a_15180_6400.n44 a_15180_6400.n43 11.6805
R1821 a_15180_6400.n45 a_15180_6400.n44 11.6805
R1822 a_15180_6400.n46 a_15180_6400.n45 11.6805
R1823 a_15180_6400.n76 a_15180_6400.n46 11.6805
R1824 a_15180_6400.n74 a_15180_6400.n47 11.6805
R1825 a_15180_6400.n70 a_15180_6400.n47 11.6805
R1826 a_15180_6400.n70 a_15180_6400.n69 11.6805
R1827 a_15180_6400.n69 a_15180_6400.n68 11.6805
R1828 a_15180_6400.n68 a_15180_6400.n49 11.6805
R1829 a_15180_6400.n64 a_15180_6400.n49 11.6805
R1830 a_15180_6400.n64 a_15180_6400.n63 11.6805
R1831 a_15180_6400.n63 a_15180_6400.n62 11.6805
R1832 a_15180_6400.n62 a_15180_6400.n51 11.6805
R1833 a_15180_6400.n58 a_15180_6400.n51 11.6805
R1834 a_15180_6400.n58 a_15180_6400.n57 11.6805
R1835 a_15180_6400.n57 a_15180_6400.n56 11.6805
R1836 a_15180_6400.n56 a_15180_6400.n53 11.6805
R1837 a_15180_6400.n140 a_15180_6400.n78 10.688
R1838 a_15180_6400.n140 a_15180_6400.n139 9.24157
R1839 a_15180_6400.n116 a_15180_6400.n115 7.17687
R1840 a_15180_6400.n93 a_15180_6400.n92 7.17687
R1841 a_15180_6400.n55 a_15180_6400.n54 7.17687
R1842 a_15180_6400.n32 a_15180_6400.n31 7.17687
R1843 a_15180_6400.n165 a_15180_6400.n164 6.5392
R1844 a_15180_6400.n142 a_15180_6400.t12 5.7796
R1845 a_15180_6400.n1 a_15180_6400.t20 5.73764
R1846 a_15180_6400.n163 a_15180_6400.t19 5.59012
R1847 a_15180_6400.n165 a_15180_6400.t45 5.54817
R1848 a_15180_6400.n142 a_15180_6400.n141 5.38537
R1849 a_15180_6400.n144 a_15180_6400.n143 5.38537
R1850 a_15180_6400.n146 a_15180_6400.n145 5.38537
R1851 a_15180_6400.n148 a_15180_6400.n147 5.38537
R1852 a_15180_6400.n150 a_15180_6400.n149 5.38537
R1853 a_15180_6400.n152 a_15180_6400.n151 5.38537
R1854 a_15180_6400.n154 a_15180_6400.n153 5.38537
R1855 a_15180_6400.n156 a_15180_6400.n155 5.38537
R1856 a_15180_6400.n158 a_15180_6400.n157 5.38537
R1857 a_15180_6400.n160 a_15180_6400.n159 5.38537
R1858 a_15180_6400.n162 a_15180_6400.n161 5.38537
R1859 a_15180_6400.n169 a_15180_6400.n168 5.32067
R1860 a_15180_6400.n1 a_15180_6400.n0 5.32067
R1861 a_15180_6400.n3 a_15180_6400.n2 5.32067
R1862 a_15180_6400.n5 a_15180_6400.n4 5.32067
R1863 a_15180_6400.n7 a_15180_6400.n6 5.32067
R1864 a_15180_6400.n9 a_15180_6400.n8 5.32067
R1865 a_15180_6400.n11 a_15180_6400.n10 5.32067
R1866 a_15180_6400.n13 a_15180_6400.n12 5.32067
R1867 a_15180_6400.n15 a_15180_6400.n14 5.32067
R1868 a_15180_6400.n17 a_15180_6400.n16 5.32067
R1869 a_15180_6400.n167 a_15180_6400.n166 5.32067
R1870 a_15180_6400.n164 a_15180_6400.n163 4.61063
R1871 a_15180_6400.n94 a_15180_6400.n93 4.42851
R1872 a_15180_6400.n115 a_15180_6400.n114 4.42851
R1873 a_15180_6400.n33 a_15180_6400.n32 4.42851
R1874 a_15180_6400.n54 a_15180_6400.n53 4.42851
R1875 a_15180_6400.n169 a_15180_6400.t1 0.228
R1876 a_15180_6400.t0 a_15180_6400.n169 0.228
R1877 a_15180_6400.n0 a_15180_6400.t7 0.228
R1878 a_15180_6400.n0 a_15180_6400.t6 0.228
R1879 a_15180_6400.n2 a_15180_6400.t44 0.228
R1880 a_15180_6400.n2 a_15180_6400.t43 0.228
R1881 a_15180_6400.n4 a_15180_6400.t36 0.228
R1882 a_15180_6400.n4 a_15180_6400.t35 0.228
R1883 a_15180_6400.n6 a_15180_6400.t40 0.228
R1884 a_15180_6400.n6 a_15180_6400.t39 0.228
R1885 a_15180_6400.n8 a_15180_6400.t30 0.228
R1886 a_15180_6400.n8 a_15180_6400.t29 0.228
R1887 a_15180_6400.n10 a_15180_6400.t24 0.228
R1888 a_15180_6400.n10 a_15180_6400.t23 0.228
R1889 a_15180_6400.n12 a_15180_6400.t34 0.228
R1890 a_15180_6400.n12 a_15180_6400.t33 0.228
R1891 a_15180_6400.n14 a_15180_6400.t5 0.228
R1892 a_15180_6400.n14 a_15180_6400.t4 0.228
R1893 a_15180_6400.n16 a_15180_6400.t32 0.228
R1894 a_15180_6400.n16 a_15180_6400.t31 0.228
R1895 a_15180_6400.n166 a_15180_6400.t26 0.228
R1896 a_15180_6400.n166 a_15180_6400.t25 0.228
R1897 a_15180_6400.n141 a_15180_6400.t28 0.20525
R1898 a_15180_6400.n141 a_15180_6400.t27 0.20525
R1899 a_15180_6400.n143 a_15180_6400.t38 0.20525
R1900 a_15180_6400.n143 a_15180_6400.t37 0.20525
R1901 a_15180_6400.n145 a_15180_6400.t22 0.20525
R1902 a_15180_6400.n145 a_15180_6400.t21 0.20525
R1903 a_15180_6400.n147 a_15180_6400.t47 0.20525
R1904 a_15180_6400.n147 a_15180_6400.t46 0.20525
R1905 a_15180_6400.n149 a_15180_6400.t42 0.20525
R1906 a_15180_6400.n149 a_15180_6400.t41 0.20525
R1907 a_15180_6400.n151 a_15180_6400.t14 0.20525
R1908 a_15180_6400.n151 a_15180_6400.t13 0.20525
R1909 a_15180_6400.n153 a_15180_6400.t9 0.20525
R1910 a_15180_6400.n153 a_15180_6400.t8 0.20525
R1911 a_15180_6400.n155 a_15180_6400.t3 0.20525
R1912 a_15180_6400.n155 a_15180_6400.t2 0.20525
R1913 a_15180_6400.n157 a_15180_6400.t18 0.20525
R1914 a_15180_6400.n157 a_15180_6400.t17 0.20525
R1915 a_15180_6400.n159 a_15180_6400.t11 0.20525
R1916 a_15180_6400.n159 a_15180_6400.t10 0.20525
R1917 a_15180_6400.n161 a_15180_6400.t16 0.20525
R1918 a_15180_6400.n161 a_15180_6400.t15 0.20525
R1919 a_15180_6400.n167 a_15180_6400.n165 0.189974
R1920 a_15180_6400.n168 a_15180_6400.n167 0.189974
R1921 a_15180_6400.n168 a_15180_6400.n17 0.189974
R1922 a_15180_6400.n17 a_15180_6400.n15 0.189974
R1923 a_15180_6400.n15 a_15180_6400.n13 0.189974
R1924 a_15180_6400.n13 a_15180_6400.n11 0.189974
R1925 a_15180_6400.n11 a_15180_6400.n9 0.189974
R1926 a_15180_6400.n9 a_15180_6400.n7 0.189974
R1927 a_15180_6400.n7 a_15180_6400.n5 0.189974
R1928 a_15180_6400.n5 a_15180_6400.n3 0.189974
R1929 a_15180_6400.n3 a_15180_6400.n1 0.189974
R1930 a_15180_6400.n163 a_15180_6400.n162 0.189974
R1931 a_15180_6400.n162 a_15180_6400.n160 0.189974
R1932 a_15180_6400.n160 a_15180_6400.n158 0.189974
R1933 a_15180_6400.n158 a_15180_6400.n156 0.189974
R1934 a_15180_6400.n156 a_15180_6400.n154 0.189974
R1935 a_15180_6400.n154 a_15180_6400.n152 0.189974
R1936 a_15180_6400.n152 a_15180_6400.n150 0.189974
R1937 a_15180_6400.n150 a_15180_6400.n148 0.189974
R1938 a_15180_6400.n148 a_15180_6400.n146 0.189974
R1939 a_15180_6400.n146 a_15180_6400.n144 0.189974
R1940 a_15180_6400.n144 a_15180_6400.n142 0.189974
R1941 a_15180_6400.n134 a_15180_6400.n79 0.1205
R1942 a_15180_6400.n134 a_15180_6400.n133 0.1205
R1943 a_15180_6400.n133 a_15180_6400.n132 0.1205
R1944 a_15180_6400.n132 a_15180_6400.n109 0.1205
R1945 a_15180_6400.n128 a_15180_6400.n109 0.1205
R1946 a_15180_6400.n128 a_15180_6400.n127 0.1205
R1947 a_15180_6400.n127 a_15180_6400.n126 0.1205
R1948 a_15180_6400.n126 a_15180_6400.n111 0.1205
R1949 a_15180_6400.n122 a_15180_6400.n111 0.1205
R1950 a_15180_6400.n122 a_15180_6400.n121 0.1205
R1951 a_15180_6400.n121 a_15180_6400.n120 0.1205
R1952 a_15180_6400.n120 a_15180_6400.n113 0.1205
R1953 a_15180_6400.n116 a_15180_6400.n113 0.1205
R1954 a_15180_6400.n92 a_15180_6400.n91 0.1205
R1955 a_15180_6400.n91 a_15180_6400.n90 0.1205
R1956 a_15180_6400.n90 a_15180_6400.n89 0.1205
R1957 a_15180_6400.n89 a_15180_6400.n88 0.1205
R1958 a_15180_6400.n88 a_15180_6400.n87 0.1205
R1959 a_15180_6400.n87 a_15180_6400.n86 0.1205
R1960 a_15180_6400.n86 a_15180_6400.n85 0.1205
R1961 a_15180_6400.n85 a_15180_6400.n84 0.1205
R1962 a_15180_6400.n84 a_15180_6400.n83 0.1205
R1963 a_15180_6400.n83 a_15180_6400.n82 0.1205
R1964 a_15180_6400.n82 a_15180_6400.n81 0.1205
R1965 a_15180_6400.n81 a_15180_6400.n80 0.1205
R1966 a_15180_6400.n138 a_15180_6400.n80 0.1205
R1967 a_15180_6400.n73 a_15180_6400.n18 0.1205
R1968 a_15180_6400.n73 a_15180_6400.n72 0.1205
R1969 a_15180_6400.n72 a_15180_6400.n71 0.1205
R1970 a_15180_6400.n71 a_15180_6400.n48 0.1205
R1971 a_15180_6400.n67 a_15180_6400.n48 0.1205
R1972 a_15180_6400.n67 a_15180_6400.n66 0.1205
R1973 a_15180_6400.n66 a_15180_6400.n65 0.1205
R1974 a_15180_6400.n65 a_15180_6400.n50 0.1205
R1975 a_15180_6400.n61 a_15180_6400.n50 0.1205
R1976 a_15180_6400.n61 a_15180_6400.n60 0.1205
R1977 a_15180_6400.n60 a_15180_6400.n59 0.1205
R1978 a_15180_6400.n59 a_15180_6400.n52 0.1205
R1979 a_15180_6400.n55 a_15180_6400.n52 0.1205
R1980 a_15180_6400.n31 a_15180_6400.n30 0.1205
R1981 a_15180_6400.n30 a_15180_6400.n29 0.1205
R1982 a_15180_6400.n29 a_15180_6400.n28 0.1205
R1983 a_15180_6400.n28 a_15180_6400.n27 0.1205
R1984 a_15180_6400.n27 a_15180_6400.n26 0.1205
R1985 a_15180_6400.n26 a_15180_6400.n25 0.1205
R1986 a_15180_6400.n25 a_15180_6400.n24 0.1205
R1987 a_15180_6400.n24 a_15180_6400.n23 0.1205
R1988 a_15180_6400.n23 a_15180_6400.n22 0.1205
R1989 a_15180_6400.n22 a_15180_6400.n21 0.1205
R1990 a_15180_6400.n21 a_15180_6400.n20 0.1205
R1991 a_15180_6400.n20 a_15180_6400.n19 0.1205
R1992 a_15180_6400.n77 a_15180_6400.n19 0.1205
R1993 a_15180_6400.n139 a_15180_6400.n79 0.0485
R1994 a_15180_6400.n139 a_15180_6400.n138 0.0485
R1995 a_15180_6400.n78 a_15180_6400.n18 0.0485
R1996 a_15180_6400.n78 a_15180_6400.n77 0.0485
R1997 a_6924_6400.n55 a_6924_6400.t39 113.632
R1998 a_6924_6400.n71 a_6924_6400.t16 113.632
R1999 a_6924_6400.n10 a_6924_6400.t63 113.632
R2000 a_6924_6400.n26 a_6924_6400.t40 113.632
R2001 a_6924_6400.n86 a_6924_6400.t27 109.174
R2002 a_6924_6400.n87 a_6924_6400.t28 109.174
R2003 a_6924_6400.n56 a_6924_6400.t38 109.174
R2004 a_6924_6400.n57 a_6924_6400.t37 109.174
R2005 a_6924_6400.n58 a_6924_6400.t36 109.174
R2006 a_6924_6400.n59 a_6924_6400.t35 109.174
R2007 a_6924_6400.n60 a_6924_6400.t34 109.174
R2008 a_6924_6400.n61 a_6924_6400.t33 109.174
R2009 a_6924_6400.n62 a_6924_6400.t32 109.174
R2010 a_6924_6400.n63 a_6924_6400.t31 109.174
R2011 a_6924_6400.n64 a_6924_6400.t30 109.174
R2012 a_6924_6400.n65 a_6924_6400.t29 109.174
R2013 a_6924_6400.n85 a_6924_6400.t26 109.174
R2014 a_6924_6400.n66 a_6924_6400.t25 109.174
R2015 a_6924_6400.n81 a_6924_6400.t24 109.174
R2016 a_6924_6400.n80 a_6924_6400.t23 109.174
R2017 a_6924_6400.n79 a_6924_6400.t22 109.174
R2018 a_6924_6400.n68 a_6924_6400.t21 109.174
R2019 a_6924_6400.n75 a_6924_6400.t20 109.174
R2020 a_6924_6400.n74 a_6924_6400.t19 109.174
R2021 a_6924_6400.n73 a_6924_6400.t18 109.174
R2022 a_6924_6400.n70 a_6924_6400.t17 109.174
R2023 a_6924_6400.n41 a_6924_6400.t51 109.174
R2024 a_6924_6400.n42 a_6924_6400.t52 109.174
R2025 a_6924_6400.n11 a_6924_6400.t62 109.174
R2026 a_6924_6400.n12 a_6924_6400.t61 109.174
R2027 a_6924_6400.n13 a_6924_6400.t60 109.174
R2028 a_6924_6400.n14 a_6924_6400.t59 109.174
R2029 a_6924_6400.n15 a_6924_6400.t58 109.174
R2030 a_6924_6400.n16 a_6924_6400.t57 109.174
R2031 a_6924_6400.n17 a_6924_6400.t56 109.174
R2032 a_6924_6400.n18 a_6924_6400.t55 109.174
R2033 a_6924_6400.n19 a_6924_6400.t54 109.174
R2034 a_6924_6400.n20 a_6924_6400.t53 109.174
R2035 a_6924_6400.n40 a_6924_6400.t50 109.174
R2036 a_6924_6400.n21 a_6924_6400.t49 109.174
R2037 a_6924_6400.n36 a_6924_6400.t48 109.174
R2038 a_6924_6400.n35 a_6924_6400.t47 109.174
R2039 a_6924_6400.n34 a_6924_6400.t46 109.174
R2040 a_6924_6400.n23 a_6924_6400.t45 109.174
R2041 a_6924_6400.n30 a_6924_6400.t44 109.174
R2042 a_6924_6400.n29 a_6924_6400.t43 109.174
R2043 a_6924_6400.n28 a_6924_6400.t42 109.174
R2044 a_6924_6400.n25 a_6924_6400.t41 109.174
R2045 a_6924_6400.n98 a_6924_6400.n90 19.4712
R2046 a_6924_6400.n86 a_6924_6400.n45 18.4942
R2047 a_6924_6400.n88 a_6924_6400.n87 18.4942
R2048 a_6924_6400.n57 a_6924_6400.n54 18.4942
R2049 a_6924_6400.n58 a_6924_6400.n53 18.4942
R2050 a_6924_6400.n59 a_6924_6400.n52 18.4942
R2051 a_6924_6400.n60 a_6924_6400.n51 18.4942
R2052 a_6924_6400.n61 a_6924_6400.n50 18.4942
R2053 a_6924_6400.n62 a_6924_6400.n49 18.4942
R2054 a_6924_6400.n63 a_6924_6400.n48 18.4942
R2055 a_6924_6400.n64 a_6924_6400.n47 18.4942
R2056 a_6924_6400.n65 a_6924_6400.n46 18.4942
R2057 a_6924_6400.n85 a_6924_6400.n84 18.4942
R2058 a_6924_6400.n83 a_6924_6400.n66 18.4942
R2059 a_6924_6400.n82 a_6924_6400.n81 18.4942
R2060 a_6924_6400.n80 a_6924_6400.n67 18.4942
R2061 a_6924_6400.n79 a_6924_6400.n78 18.4942
R2062 a_6924_6400.n77 a_6924_6400.n68 18.4942
R2063 a_6924_6400.n76 a_6924_6400.n75 18.4942
R2064 a_6924_6400.n74 a_6924_6400.n69 18.4942
R2065 a_6924_6400.n73 a_6924_6400.n72 18.4942
R2066 a_6924_6400.n41 a_6924_6400.n0 18.4942
R2067 a_6924_6400.n43 a_6924_6400.n42 18.4942
R2068 a_6924_6400.n12 a_6924_6400.n9 18.4942
R2069 a_6924_6400.n13 a_6924_6400.n8 18.4942
R2070 a_6924_6400.n14 a_6924_6400.n7 18.4942
R2071 a_6924_6400.n15 a_6924_6400.n6 18.4942
R2072 a_6924_6400.n16 a_6924_6400.n5 18.4942
R2073 a_6924_6400.n17 a_6924_6400.n4 18.4942
R2074 a_6924_6400.n18 a_6924_6400.n3 18.4942
R2075 a_6924_6400.n19 a_6924_6400.n2 18.4942
R2076 a_6924_6400.n20 a_6924_6400.n1 18.4942
R2077 a_6924_6400.n40 a_6924_6400.n39 18.4942
R2078 a_6924_6400.n38 a_6924_6400.n21 18.4942
R2079 a_6924_6400.n37 a_6924_6400.n36 18.4942
R2080 a_6924_6400.n35 a_6924_6400.n22 18.4942
R2081 a_6924_6400.n34 a_6924_6400.n33 18.4942
R2082 a_6924_6400.n32 a_6924_6400.n23 18.4942
R2083 a_6924_6400.n31 a_6924_6400.n30 18.4942
R2084 a_6924_6400.n29 a_6924_6400.n24 18.4942
R2085 a_6924_6400.n28 a_6924_6400.n27 18.4942
R2086 a_6924_6400.n86 a_6924_6400.n85 11.6805
R2087 a_6924_6400.n87 a_6924_6400.n86 11.6805
R2088 a_6924_6400.n57 a_6924_6400.n56 11.6805
R2089 a_6924_6400.n58 a_6924_6400.n57 11.6805
R2090 a_6924_6400.n59 a_6924_6400.n58 11.6805
R2091 a_6924_6400.n60 a_6924_6400.n59 11.6805
R2092 a_6924_6400.n61 a_6924_6400.n60 11.6805
R2093 a_6924_6400.n62 a_6924_6400.n61 11.6805
R2094 a_6924_6400.n63 a_6924_6400.n62 11.6805
R2095 a_6924_6400.n64 a_6924_6400.n63 11.6805
R2096 a_6924_6400.n65 a_6924_6400.n64 11.6805
R2097 a_6924_6400.n87 a_6924_6400.n65 11.6805
R2098 a_6924_6400.n85 a_6924_6400.n66 11.6805
R2099 a_6924_6400.n81 a_6924_6400.n66 11.6805
R2100 a_6924_6400.n81 a_6924_6400.n80 11.6805
R2101 a_6924_6400.n80 a_6924_6400.n79 11.6805
R2102 a_6924_6400.n79 a_6924_6400.n68 11.6805
R2103 a_6924_6400.n75 a_6924_6400.n68 11.6805
R2104 a_6924_6400.n75 a_6924_6400.n74 11.6805
R2105 a_6924_6400.n74 a_6924_6400.n73 11.6805
R2106 a_6924_6400.n73 a_6924_6400.n70 11.6805
R2107 a_6924_6400.n41 a_6924_6400.n40 11.6805
R2108 a_6924_6400.n42 a_6924_6400.n41 11.6805
R2109 a_6924_6400.n12 a_6924_6400.n11 11.6805
R2110 a_6924_6400.n13 a_6924_6400.n12 11.6805
R2111 a_6924_6400.n14 a_6924_6400.n13 11.6805
R2112 a_6924_6400.n15 a_6924_6400.n14 11.6805
R2113 a_6924_6400.n16 a_6924_6400.n15 11.6805
R2114 a_6924_6400.n17 a_6924_6400.n16 11.6805
R2115 a_6924_6400.n18 a_6924_6400.n17 11.6805
R2116 a_6924_6400.n19 a_6924_6400.n18 11.6805
R2117 a_6924_6400.n20 a_6924_6400.n19 11.6805
R2118 a_6924_6400.n42 a_6924_6400.n20 11.6805
R2119 a_6924_6400.n40 a_6924_6400.n21 11.6805
R2120 a_6924_6400.n36 a_6924_6400.n21 11.6805
R2121 a_6924_6400.n36 a_6924_6400.n35 11.6805
R2122 a_6924_6400.n35 a_6924_6400.n34 11.6805
R2123 a_6924_6400.n34 a_6924_6400.n23 11.6805
R2124 a_6924_6400.n30 a_6924_6400.n23 11.6805
R2125 a_6924_6400.n30 a_6924_6400.n29 11.6805
R2126 a_6924_6400.n29 a_6924_6400.n28 11.6805
R2127 a_6924_6400.n28 a_6924_6400.n25 11.6805
R2128 a_6924_6400.n90 a_6924_6400.n44 10.013
R2129 a_6924_6400.n90 a_6924_6400.n89 9.91657
R2130 a_6924_6400.n72 a_6924_6400.n71 7.17687
R2131 a_6924_6400.n55 a_6924_6400.n54 7.17687
R2132 a_6924_6400.n27 a_6924_6400.n26 7.17687
R2133 a_6924_6400.n10 a_6924_6400.n9 7.17687
R2134 a_6924_6400.n99 a_6924_6400.n98 6.5392
R2135 a_6924_6400.n92 a_6924_6400.t15 5.7796
R2136 a_6924_6400.t7 a_6924_6400.n105 5.73764
R2137 a_6924_6400.n97 a_6924_6400.t8 5.59012
R2138 a_6924_6400.n99 a_6924_6400.t0 5.54817
R2139 a_6924_6400.n92 a_6924_6400.n91 5.38537
R2140 a_6924_6400.n94 a_6924_6400.n93 5.38537
R2141 a_6924_6400.n96 a_6924_6400.n95 5.38537
R2142 a_6924_6400.n105 a_6924_6400.n104 5.32067
R2143 a_6924_6400.n103 a_6924_6400.n102 5.32067
R2144 a_6924_6400.n101 a_6924_6400.n100 5.32067
R2145 a_6924_6400.n98 a_6924_6400.n97 4.61063
R2146 a_6924_6400.n56 a_6924_6400.n55 4.42851
R2147 a_6924_6400.n71 a_6924_6400.n70 4.42851
R2148 a_6924_6400.n11 a_6924_6400.n10 4.42851
R2149 a_6924_6400.n26 a_6924_6400.n25 4.42851
R2150 a_6924_6400.n104 a_6924_6400.t5 0.228
R2151 a_6924_6400.n104 a_6924_6400.t6 0.228
R2152 a_6924_6400.n102 a_6924_6400.t3 0.228
R2153 a_6924_6400.n102 a_6924_6400.t4 0.228
R2154 a_6924_6400.n100 a_6924_6400.t1 0.228
R2155 a_6924_6400.n100 a_6924_6400.t2 0.228
R2156 a_6924_6400.n91 a_6924_6400.t13 0.20525
R2157 a_6924_6400.n91 a_6924_6400.t14 0.20525
R2158 a_6924_6400.n93 a_6924_6400.t11 0.20525
R2159 a_6924_6400.n93 a_6924_6400.t12 0.20525
R2160 a_6924_6400.n95 a_6924_6400.t9 0.20525
R2161 a_6924_6400.n95 a_6924_6400.t10 0.20525
R2162 a_6924_6400.n101 a_6924_6400.n99 0.189974
R2163 a_6924_6400.n103 a_6924_6400.n101 0.189974
R2164 a_6924_6400.n105 a_6924_6400.n103 0.189974
R2165 a_6924_6400.n97 a_6924_6400.n96 0.189974
R2166 a_6924_6400.n96 a_6924_6400.n94 0.189974
R2167 a_6924_6400.n94 a_6924_6400.n92 0.189974
R2168 a_6924_6400.n84 a_6924_6400.n45 0.1205
R2169 a_6924_6400.n84 a_6924_6400.n83 0.1205
R2170 a_6924_6400.n83 a_6924_6400.n82 0.1205
R2171 a_6924_6400.n82 a_6924_6400.n67 0.1205
R2172 a_6924_6400.n78 a_6924_6400.n67 0.1205
R2173 a_6924_6400.n78 a_6924_6400.n77 0.1205
R2174 a_6924_6400.n77 a_6924_6400.n76 0.1205
R2175 a_6924_6400.n76 a_6924_6400.n69 0.1205
R2176 a_6924_6400.n72 a_6924_6400.n69 0.1205
R2177 a_6924_6400.n54 a_6924_6400.n53 0.1205
R2178 a_6924_6400.n53 a_6924_6400.n52 0.1205
R2179 a_6924_6400.n52 a_6924_6400.n51 0.1205
R2180 a_6924_6400.n51 a_6924_6400.n50 0.1205
R2181 a_6924_6400.n50 a_6924_6400.n49 0.1205
R2182 a_6924_6400.n49 a_6924_6400.n48 0.1205
R2183 a_6924_6400.n48 a_6924_6400.n47 0.1205
R2184 a_6924_6400.n47 a_6924_6400.n46 0.1205
R2185 a_6924_6400.n88 a_6924_6400.n46 0.1205
R2186 a_6924_6400.n39 a_6924_6400.n0 0.1205
R2187 a_6924_6400.n39 a_6924_6400.n38 0.1205
R2188 a_6924_6400.n38 a_6924_6400.n37 0.1205
R2189 a_6924_6400.n37 a_6924_6400.n22 0.1205
R2190 a_6924_6400.n33 a_6924_6400.n22 0.1205
R2191 a_6924_6400.n33 a_6924_6400.n32 0.1205
R2192 a_6924_6400.n32 a_6924_6400.n31 0.1205
R2193 a_6924_6400.n31 a_6924_6400.n24 0.1205
R2194 a_6924_6400.n27 a_6924_6400.n24 0.1205
R2195 a_6924_6400.n9 a_6924_6400.n8 0.1205
R2196 a_6924_6400.n8 a_6924_6400.n7 0.1205
R2197 a_6924_6400.n7 a_6924_6400.n6 0.1205
R2198 a_6924_6400.n6 a_6924_6400.n5 0.1205
R2199 a_6924_6400.n5 a_6924_6400.n4 0.1205
R2200 a_6924_6400.n4 a_6924_6400.n3 0.1205
R2201 a_6924_6400.n3 a_6924_6400.n2 0.1205
R2202 a_6924_6400.n2 a_6924_6400.n1 0.1205
R2203 a_6924_6400.n43 a_6924_6400.n1 0.1205
R2204 a_6924_6400.n89 a_6924_6400.n45 0.0485
R2205 a_6924_6400.n89 a_6924_6400.n88 0.0485
R2206 a_6924_6400.n44 a_6924_6400.n0 0.0485
R2207 a_6924_6400.n44 a_6924_6400.n43 0.0485
R2208 a_4812_6400.n15 a_4812_6400.t15 113.632
R2209 a_4812_6400.n19 a_4812_6400.t8 113.632
R2210 a_4812_6400.n2 a_4812_6400.t23 113.632
R2211 a_4812_6400.n6 a_4812_6400.t16 113.632
R2212 a_4812_6400.n22 a_4812_6400.t11 109.174
R2213 a_4812_6400.n23 a_4812_6400.t12 109.174
R2214 a_4812_6400.n16 a_4812_6400.t14 109.174
R2215 a_4812_6400.n17 a_4812_6400.t13 109.174
R2216 a_4812_6400.n21 a_4812_6400.t10 109.174
R2217 a_4812_6400.n18 a_4812_6400.t9 109.174
R2218 a_4812_6400.n9 a_4812_6400.t19 109.174
R2219 a_4812_6400.n10 a_4812_6400.t20 109.174
R2220 a_4812_6400.n3 a_4812_6400.t22 109.174
R2221 a_4812_6400.n4 a_4812_6400.t21 109.174
R2222 a_4812_6400.n8 a_4812_6400.t18 109.174
R2223 a_4812_6400.n5 a_4812_6400.t17 109.174
R2224 a_4812_6400.n22 a_4812_6400.n13 18.4942
R2225 a_4812_6400.n24 a_4812_6400.n23 18.4942
R2226 a_4812_6400.n17 a_4812_6400.n14 18.4942
R2227 a_4812_6400.n21 a_4812_6400.n20 18.4942
R2228 a_4812_6400.n9 a_4812_6400.n0 18.4942
R2229 a_4812_6400.n11 a_4812_6400.n10 18.4942
R2230 a_4812_6400.n4 a_4812_6400.n1 18.4942
R2231 a_4812_6400.n8 a_4812_6400.n7 18.4942
R2232 a_4812_6400.n30 a_4812_6400.n26 17.9305
R2233 a_4812_6400.n22 a_4812_6400.n21 11.6805
R2234 a_4812_6400.n23 a_4812_6400.n22 11.6805
R2235 a_4812_6400.n17 a_4812_6400.n16 11.6805
R2236 a_4812_6400.n23 a_4812_6400.n17 11.6805
R2237 a_4812_6400.n21 a_4812_6400.n18 11.6805
R2238 a_4812_6400.n9 a_4812_6400.n8 11.6805
R2239 a_4812_6400.n10 a_4812_6400.n9 11.6805
R2240 a_4812_6400.n4 a_4812_6400.n3 11.6805
R2241 a_4812_6400.n10 a_4812_6400.n4 11.6805
R2242 a_4812_6400.n8 a_4812_6400.n5 11.6805
R2243 a_4812_6400.n26 a_4812_6400.n12 10.3505
R2244 a_4812_6400.n26 a_4812_6400.n25 9.57907
R2245 a_4812_6400.n20 a_4812_6400.n19 7.17687
R2246 a_4812_6400.n15 a_4812_6400.n14 7.17687
R2247 a_4812_6400.n7 a_4812_6400.n6 7.17687
R2248 a_4812_6400.n2 a_4812_6400.n1 7.17687
R2249 a_4812_6400.n31 a_4812_6400.n30 6.5392
R2250 a_4812_6400.n28 a_4812_6400.t7 5.7796
R2251 a_4812_6400.t3 a_4812_6400.n33 5.73764
R2252 a_4812_6400.n29 a_4812_6400.t4 5.59012
R2253 a_4812_6400.n31 a_4812_6400.t0 5.54817
R2254 a_4812_6400.n28 a_4812_6400.n27 5.38537
R2255 a_4812_6400.n33 a_4812_6400.n32 5.32067
R2256 a_4812_6400.n30 a_4812_6400.n29 4.61063
R2257 a_4812_6400.n16 a_4812_6400.n15 4.42851
R2258 a_4812_6400.n19 a_4812_6400.n18 4.42851
R2259 a_4812_6400.n3 a_4812_6400.n2 4.42851
R2260 a_4812_6400.n6 a_4812_6400.n5 4.42851
R2261 a_4812_6400.n32 a_4812_6400.t1 0.228
R2262 a_4812_6400.n32 a_4812_6400.t2 0.228
R2263 a_4812_6400.n27 a_4812_6400.t5 0.20525
R2264 a_4812_6400.n27 a_4812_6400.t6 0.20525
R2265 a_4812_6400.n33 a_4812_6400.n31 0.189974
R2266 a_4812_6400.n29 a_4812_6400.n28 0.189974
R2267 a_4812_6400.n20 a_4812_6400.n13 0.1205
R2268 a_4812_6400.n24 a_4812_6400.n14 0.1205
R2269 a_4812_6400.n7 a_4812_6400.n0 0.1205
R2270 a_4812_6400.n11 a_4812_6400.n1 0.1205
R2271 a_4812_6400.n25 a_4812_6400.n13 0.0485
R2272 a_4812_6400.n25 a_4812_6400.n24 0.0485
R2273 a_4812_6400.n12 a_4812_6400.n0 0.0485
R2274 a_4812_6400.n12 a_4812_6400.n11 0.0485
R2275 a_2700_6400.n15 a_2700_6400.t15 113.632
R2276 a_2700_6400.n19 a_2700_6400.t8 113.632
R2277 a_2700_6400.n2 a_2700_6400.t23 113.632
R2278 a_2700_6400.n6 a_2700_6400.t16 113.632
R2279 a_2700_6400.n22 a_2700_6400.t11 109.174
R2280 a_2700_6400.n23 a_2700_6400.t12 109.174
R2281 a_2700_6400.n16 a_2700_6400.t14 109.174
R2282 a_2700_6400.n17 a_2700_6400.t13 109.174
R2283 a_2700_6400.n21 a_2700_6400.t10 109.174
R2284 a_2700_6400.n18 a_2700_6400.t9 109.174
R2285 a_2700_6400.n9 a_2700_6400.t19 109.174
R2286 a_2700_6400.n10 a_2700_6400.t20 109.174
R2287 a_2700_6400.n3 a_2700_6400.t22 109.174
R2288 a_2700_6400.n4 a_2700_6400.t21 109.174
R2289 a_2700_6400.n8 a_2700_6400.t18 109.174
R2290 a_2700_6400.n5 a_2700_6400.t17 109.174
R2291 a_2700_6400.n22 a_2700_6400.n13 18.4942
R2292 a_2700_6400.n24 a_2700_6400.n23 18.4942
R2293 a_2700_6400.n17 a_2700_6400.n14 18.4942
R2294 a_2700_6400.n21 a_2700_6400.n20 18.4942
R2295 a_2700_6400.n9 a_2700_6400.n0 18.4942
R2296 a_2700_6400.n11 a_2700_6400.n10 18.4942
R2297 a_2700_6400.n4 a_2700_6400.n1 18.4942
R2298 a_2700_6400.n8 a_2700_6400.n7 18.4942
R2299 a_2700_6400.n30 a_2700_6400.n26 17.6419
R2300 a_2700_6400.n22 a_2700_6400.n21 11.6805
R2301 a_2700_6400.n23 a_2700_6400.n22 11.6805
R2302 a_2700_6400.n17 a_2700_6400.n16 11.6805
R2303 a_2700_6400.n23 a_2700_6400.n17 11.6805
R2304 a_2700_6400.n21 a_2700_6400.n18 11.6805
R2305 a_2700_6400.n9 a_2700_6400.n8 11.6805
R2306 a_2700_6400.n10 a_2700_6400.n9 11.6805
R2307 a_2700_6400.n4 a_2700_6400.n3 11.6805
R2308 a_2700_6400.n10 a_2700_6400.n4 11.6805
R2309 a_2700_6400.n8 a_2700_6400.n5 11.6805
R2310 a_2700_6400.n26 a_2700_6400.n12 10.688
R2311 a_2700_6400.n26 a_2700_6400.n25 9.24157
R2312 a_2700_6400.n20 a_2700_6400.n19 7.17687
R2313 a_2700_6400.n15 a_2700_6400.n14 7.17687
R2314 a_2700_6400.n7 a_2700_6400.n6 7.17687
R2315 a_2700_6400.n2 a_2700_6400.n1 7.17687
R2316 a_2700_6400.n31 a_2700_6400.n30 6.5392
R2317 a_2700_6400.n28 a_2700_6400.t7 5.7796
R2318 a_2700_6400.t3 a_2700_6400.n33 5.73764
R2319 a_2700_6400.n29 a_2700_6400.t4 5.59012
R2320 a_2700_6400.n31 a_2700_6400.t0 5.54817
R2321 a_2700_6400.n28 a_2700_6400.n27 5.38537
R2322 a_2700_6400.n33 a_2700_6400.n32 5.32067
R2323 a_2700_6400.n30 a_2700_6400.n29 4.61063
R2324 a_2700_6400.n16 a_2700_6400.n15 4.42851
R2325 a_2700_6400.n19 a_2700_6400.n18 4.42851
R2326 a_2700_6400.n3 a_2700_6400.n2 4.42851
R2327 a_2700_6400.n6 a_2700_6400.n5 4.42851
R2328 a_2700_6400.n32 a_2700_6400.t1 0.228
R2329 a_2700_6400.n32 a_2700_6400.t2 0.228
R2330 a_2700_6400.n27 a_2700_6400.t5 0.20525
R2331 a_2700_6400.n27 a_2700_6400.t6 0.20525
R2332 a_2700_6400.n33 a_2700_6400.n31 0.189974
R2333 a_2700_6400.n29 a_2700_6400.n28 0.189974
R2334 a_2700_6400.n20 a_2700_6400.n13 0.1205
R2335 a_2700_6400.n24 a_2700_6400.n14 0.1205
R2336 a_2700_6400.n7 a_2700_6400.n0 0.1205
R2337 a_2700_6400.n11 a_2700_6400.n1 0.1205
R2338 a_2700_6400.n25 a_2700_6400.n13 0.0485
R2339 a_2700_6400.n25 a_2700_6400.n24 0.0485
R2340 a_2700_6400.n12 a_2700_6400.n0 0.0485
R2341 a_2700_6400.n12 a_2700_6400.n11 0.0485
R2342 a_15180_41600.n97 a_15180_41600.t79 113.632
R2343 a_15180_41600.n119 a_15180_41600.t48 113.632
R2344 a_15180_41600.n36 a_15180_41600.t111 113.632
R2345 a_15180_41600.n58 a_15180_41600.t80 113.632
R2346 a_15180_41600.n140 a_15180_41600.t63 109.174
R2347 a_15180_41600.n141 a_15180_41600.t64 109.174
R2348 a_15180_41600.n98 a_15180_41600.t78 109.174
R2349 a_15180_41600.n99 a_15180_41600.t77 109.174
R2350 a_15180_41600.n100 a_15180_41600.t76 109.174
R2351 a_15180_41600.n101 a_15180_41600.t75 109.174
R2352 a_15180_41600.n102 a_15180_41600.t74 109.174
R2353 a_15180_41600.n103 a_15180_41600.t73 109.174
R2354 a_15180_41600.n104 a_15180_41600.t72 109.174
R2355 a_15180_41600.n105 a_15180_41600.t71 109.174
R2356 a_15180_41600.n106 a_15180_41600.t70 109.174
R2357 a_15180_41600.n107 a_15180_41600.t69 109.174
R2358 a_15180_41600.n108 a_15180_41600.t68 109.174
R2359 a_15180_41600.n109 a_15180_41600.t67 109.174
R2360 a_15180_41600.n110 a_15180_41600.t66 109.174
R2361 a_15180_41600.n111 a_15180_41600.t65 109.174
R2362 a_15180_41600.n139 a_15180_41600.t62 109.174
R2363 a_15180_41600.n112 a_15180_41600.t61 109.174
R2364 a_15180_41600.n135 a_15180_41600.t60 109.174
R2365 a_15180_41600.n134 a_15180_41600.t59 109.174
R2366 a_15180_41600.n133 a_15180_41600.t58 109.174
R2367 a_15180_41600.n114 a_15180_41600.t57 109.174
R2368 a_15180_41600.n129 a_15180_41600.t56 109.174
R2369 a_15180_41600.n128 a_15180_41600.t55 109.174
R2370 a_15180_41600.n127 a_15180_41600.t54 109.174
R2371 a_15180_41600.n116 a_15180_41600.t53 109.174
R2372 a_15180_41600.n123 a_15180_41600.t52 109.174
R2373 a_15180_41600.n122 a_15180_41600.t51 109.174
R2374 a_15180_41600.n121 a_15180_41600.t50 109.174
R2375 a_15180_41600.n118 a_15180_41600.t49 109.174
R2376 a_15180_41600.n79 a_15180_41600.t95 109.174
R2377 a_15180_41600.n80 a_15180_41600.t96 109.174
R2378 a_15180_41600.n37 a_15180_41600.t110 109.174
R2379 a_15180_41600.n38 a_15180_41600.t109 109.174
R2380 a_15180_41600.n39 a_15180_41600.t108 109.174
R2381 a_15180_41600.n40 a_15180_41600.t107 109.174
R2382 a_15180_41600.n41 a_15180_41600.t106 109.174
R2383 a_15180_41600.n42 a_15180_41600.t105 109.174
R2384 a_15180_41600.n43 a_15180_41600.t104 109.174
R2385 a_15180_41600.n44 a_15180_41600.t103 109.174
R2386 a_15180_41600.n45 a_15180_41600.t102 109.174
R2387 a_15180_41600.n46 a_15180_41600.t101 109.174
R2388 a_15180_41600.n47 a_15180_41600.t100 109.174
R2389 a_15180_41600.n48 a_15180_41600.t99 109.174
R2390 a_15180_41600.n49 a_15180_41600.t98 109.174
R2391 a_15180_41600.n50 a_15180_41600.t97 109.174
R2392 a_15180_41600.n78 a_15180_41600.t94 109.174
R2393 a_15180_41600.n51 a_15180_41600.t93 109.174
R2394 a_15180_41600.n74 a_15180_41600.t92 109.174
R2395 a_15180_41600.n73 a_15180_41600.t91 109.174
R2396 a_15180_41600.n72 a_15180_41600.t90 109.174
R2397 a_15180_41600.n53 a_15180_41600.t89 109.174
R2398 a_15180_41600.n68 a_15180_41600.t88 109.174
R2399 a_15180_41600.n67 a_15180_41600.t87 109.174
R2400 a_15180_41600.n66 a_15180_41600.t86 109.174
R2401 a_15180_41600.n55 a_15180_41600.t85 109.174
R2402 a_15180_41600.n62 a_15180_41600.t84 109.174
R2403 a_15180_41600.n61 a_15180_41600.t83 109.174
R2404 a_15180_41600.n60 a_15180_41600.t82 109.174
R2405 a_15180_41600.n57 a_15180_41600.t81 109.174
R2406 a_15180_41600.n140 a_15180_41600.n83 18.4942
R2407 a_15180_41600.n142 a_15180_41600.n141 18.4942
R2408 a_15180_41600.n99 a_15180_41600.n96 18.4942
R2409 a_15180_41600.n100 a_15180_41600.n95 18.4942
R2410 a_15180_41600.n101 a_15180_41600.n94 18.4942
R2411 a_15180_41600.n102 a_15180_41600.n93 18.4942
R2412 a_15180_41600.n103 a_15180_41600.n92 18.4942
R2413 a_15180_41600.n104 a_15180_41600.n91 18.4942
R2414 a_15180_41600.n105 a_15180_41600.n90 18.4942
R2415 a_15180_41600.n106 a_15180_41600.n89 18.4942
R2416 a_15180_41600.n107 a_15180_41600.n88 18.4942
R2417 a_15180_41600.n108 a_15180_41600.n87 18.4942
R2418 a_15180_41600.n109 a_15180_41600.n86 18.4942
R2419 a_15180_41600.n110 a_15180_41600.n85 18.4942
R2420 a_15180_41600.n111 a_15180_41600.n84 18.4942
R2421 a_15180_41600.n139 a_15180_41600.n138 18.4942
R2422 a_15180_41600.n137 a_15180_41600.n112 18.4942
R2423 a_15180_41600.n136 a_15180_41600.n135 18.4942
R2424 a_15180_41600.n134 a_15180_41600.n113 18.4942
R2425 a_15180_41600.n133 a_15180_41600.n132 18.4942
R2426 a_15180_41600.n131 a_15180_41600.n114 18.4942
R2427 a_15180_41600.n130 a_15180_41600.n129 18.4942
R2428 a_15180_41600.n128 a_15180_41600.n115 18.4942
R2429 a_15180_41600.n127 a_15180_41600.n126 18.4942
R2430 a_15180_41600.n125 a_15180_41600.n116 18.4942
R2431 a_15180_41600.n124 a_15180_41600.n123 18.4942
R2432 a_15180_41600.n122 a_15180_41600.n117 18.4942
R2433 a_15180_41600.n121 a_15180_41600.n120 18.4942
R2434 a_15180_41600.n79 a_15180_41600.n22 18.4942
R2435 a_15180_41600.n81 a_15180_41600.n80 18.4942
R2436 a_15180_41600.n38 a_15180_41600.n35 18.4942
R2437 a_15180_41600.n39 a_15180_41600.n34 18.4942
R2438 a_15180_41600.n40 a_15180_41600.n33 18.4942
R2439 a_15180_41600.n41 a_15180_41600.n32 18.4942
R2440 a_15180_41600.n42 a_15180_41600.n31 18.4942
R2441 a_15180_41600.n43 a_15180_41600.n30 18.4942
R2442 a_15180_41600.n44 a_15180_41600.n29 18.4942
R2443 a_15180_41600.n45 a_15180_41600.n28 18.4942
R2444 a_15180_41600.n46 a_15180_41600.n27 18.4942
R2445 a_15180_41600.n47 a_15180_41600.n26 18.4942
R2446 a_15180_41600.n48 a_15180_41600.n25 18.4942
R2447 a_15180_41600.n49 a_15180_41600.n24 18.4942
R2448 a_15180_41600.n50 a_15180_41600.n23 18.4942
R2449 a_15180_41600.n78 a_15180_41600.n77 18.4942
R2450 a_15180_41600.n76 a_15180_41600.n51 18.4942
R2451 a_15180_41600.n75 a_15180_41600.n74 18.4942
R2452 a_15180_41600.n73 a_15180_41600.n52 18.4942
R2453 a_15180_41600.n72 a_15180_41600.n71 18.4942
R2454 a_15180_41600.n70 a_15180_41600.n53 18.4942
R2455 a_15180_41600.n69 a_15180_41600.n68 18.4942
R2456 a_15180_41600.n67 a_15180_41600.n54 18.4942
R2457 a_15180_41600.n66 a_15180_41600.n65 18.4942
R2458 a_15180_41600.n64 a_15180_41600.n55 18.4942
R2459 a_15180_41600.n63 a_15180_41600.n62 18.4942
R2460 a_15180_41600.n61 a_15180_41600.n56 18.4942
R2461 a_15180_41600.n60 a_15180_41600.n59 18.4942
R2462 a_15180_41600.n168 a_15180_41600.n144 17.8923
R2463 a_15180_41600.n140 a_15180_41600.n139 11.6805
R2464 a_15180_41600.n141 a_15180_41600.n140 11.6805
R2465 a_15180_41600.n99 a_15180_41600.n98 11.6805
R2466 a_15180_41600.n100 a_15180_41600.n99 11.6805
R2467 a_15180_41600.n101 a_15180_41600.n100 11.6805
R2468 a_15180_41600.n102 a_15180_41600.n101 11.6805
R2469 a_15180_41600.n103 a_15180_41600.n102 11.6805
R2470 a_15180_41600.n104 a_15180_41600.n103 11.6805
R2471 a_15180_41600.n105 a_15180_41600.n104 11.6805
R2472 a_15180_41600.n106 a_15180_41600.n105 11.6805
R2473 a_15180_41600.n107 a_15180_41600.n106 11.6805
R2474 a_15180_41600.n108 a_15180_41600.n107 11.6805
R2475 a_15180_41600.n109 a_15180_41600.n108 11.6805
R2476 a_15180_41600.n110 a_15180_41600.n109 11.6805
R2477 a_15180_41600.n111 a_15180_41600.n110 11.6805
R2478 a_15180_41600.n141 a_15180_41600.n111 11.6805
R2479 a_15180_41600.n139 a_15180_41600.n112 11.6805
R2480 a_15180_41600.n135 a_15180_41600.n112 11.6805
R2481 a_15180_41600.n135 a_15180_41600.n134 11.6805
R2482 a_15180_41600.n134 a_15180_41600.n133 11.6805
R2483 a_15180_41600.n133 a_15180_41600.n114 11.6805
R2484 a_15180_41600.n129 a_15180_41600.n114 11.6805
R2485 a_15180_41600.n129 a_15180_41600.n128 11.6805
R2486 a_15180_41600.n128 a_15180_41600.n127 11.6805
R2487 a_15180_41600.n127 a_15180_41600.n116 11.6805
R2488 a_15180_41600.n123 a_15180_41600.n116 11.6805
R2489 a_15180_41600.n123 a_15180_41600.n122 11.6805
R2490 a_15180_41600.n122 a_15180_41600.n121 11.6805
R2491 a_15180_41600.n121 a_15180_41600.n118 11.6805
R2492 a_15180_41600.n79 a_15180_41600.n78 11.6805
R2493 a_15180_41600.n80 a_15180_41600.n79 11.6805
R2494 a_15180_41600.n38 a_15180_41600.n37 11.6805
R2495 a_15180_41600.n39 a_15180_41600.n38 11.6805
R2496 a_15180_41600.n40 a_15180_41600.n39 11.6805
R2497 a_15180_41600.n41 a_15180_41600.n40 11.6805
R2498 a_15180_41600.n42 a_15180_41600.n41 11.6805
R2499 a_15180_41600.n43 a_15180_41600.n42 11.6805
R2500 a_15180_41600.n44 a_15180_41600.n43 11.6805
R2501 a_15180_41600.n45 a_15180_41600.n44 11.6805
R2502 a_15180_41600.n46 a_15180_41600.n45 11.6805
R2503 a_15180_41600.n47 a_15180_41600.n46 11.6805
R2504 a_15180_41600.n48 a_15180_41600.n47 11.6805
R2505 a_15180_41600.n49 a_15180_41600.n48 11.6805
R2506 a_15180_41600.n50 a_15180_41600.n49 11.6805
R2507 a_15180_41600.n80 a_15180_41600.n50 11.6805
R2508 a_15180_41600.n78 a_15180_41600.n51 11.6805
R2509 a_15180_41600.n74 a_15180_41600.n51 11.6805
R2510 a_15180_41600.n74 a_15180_41600.n73 11.6805
R2511 a_15180_41600.n73 a_15180_41600.n72 11.6805
R2512 a_15180_41600.n72 a_15180_41600.n53 11.6805
R2513 a_15180_41600.n68 a_15180_41600.n53 11.6805
R2514 a_15180_41600.n68 a_15180_41600.n67 11.6805
R2515 a_15180_41600.n67 a_15180_41600.n66 11.6805
R2516 a_15180_41600.n66 a_15180_41600.n55 11.6805
R2517 a_15180_41600.n62 a_15180_41600.n55 11.6805
R2518 a_15180_41600.n62 a_15180_41600.n61 11.6805
R2519 a_15180_41600.n61 a_15180_41600.n60 11.6805
R2520 a_15180_41600.n60 a_15180_41600.n57 11.6805
R2521 a_15180_41600.n144 a_15180_41600.n82 10.688
R2522 a_15180_41600.n144 a_15180_41600.n143 9.24157
R2523 a_15180_41600.n120 a_15180_41600.n119 7.17687
R2524 a_15180_41600.n97 a_15180_41600.n96 7.17687
R2525 a_15180_41600.n59 a_15180_41600.n58 7.17687
R2526 a_15180_41600.n36 a_15180_41600.n35 7.17687
R2527 a_15180_41600.n169 a_15180_41600.n168 6.5392
R2528 a_15180_41600.n146 a_15180_41600.t27 5.7796
R2529 a_15180_41600.n1 a_15180_41600.t31 5.73764
R2530 a_15180_41600.n167 a_15180_41600.t30 5.59012
R2531 a_15180_41600.t0 a_15180_41600.n169 5.54817
R2532 a_15180_41600.n146 a_15180_41600.n145 5.38537
R2533 a_15180_41600.n148 a_15180_41600.n147 5.38537
R2534 a_15180_41600.n150 a_15180_41600.n149 5.38537
R2535 a_15180_41600.n152 a_15180_41600.n151 5.38537
R2536 a_15180_41600.n154 a_15180_41600.n153 5.38537
R2537 a_15180_41600.n156 a_15180_41600.n155 5.38537
R2538 a_15180_41600.n158 a_15180_41600.n157 5.38537
R2539 a_15180_41600.n160 a_15180_41600.n159 5.38537
R2540 a_15180_41600.n162 a_15180_41600.n161 5.38537
R2541 a_15180_41600.n164 a_15180_41600.n163 5.38537
R2542 a_15180_41600.n166 a_15180_41600.n165 5.38537
R2543 a_15180_41600.n1 a_15180_41600.n0 5.32067
R2544 a_15180_41600.n3 a_15180_41600.n2 5.32067
R2545 a_15180_41600.n5 a_15180_41600.n4 5.32067
R2546 a_15180_41600.n7 a_15180_41600.n6 5.32067
R2547 a_15180_41600.n9 a_15180_41600.n8 5.32067
R2548 a_15180_41600.n11 a_15180_41600.n10 5.32067
R2549 a_15180_41600.n13 a_15180_41600.n12 5.32067
R2550 a_15180_41600.n15 a_15180_41600.n14 5.32067
R2551 a_15180_41600.n17 a_15180_41600.n16 5.32067
R2552 a_15180_41600.n19 a_15180_41600.n18 5.32067
R2553 a_15180_41600.n21 a_15180_41600.n20 5.32067
R2554 a_15180_41600.n168 a_15180_41600.n167 4.61063
R2555 a_15180_41600.n98 a_15180_41600.n97 4.42851
R2556 a_15180_41600.n119 a_15180_41600.n118 4.42851
R2557 a_15180_41600.n37 a_15180_41600.n36 4.42851
R2558 a_15180_41600.n58 a_15180_41600.n57 4.42851
R2559 a_15180_41600.n0 a_15180_41600.t45 0.228
R2560 a_15180_41600.n0 a_15180_41600.t44 0.228
R2561 a_15180_41600.n2 a_15180_41600.t26 0.228
R2562 a_15180_41600.n2 a_15180_41600.t25 0.228
R2563 a_15180_41600.n4 a_15180_41600.t36 0.228
R2564 a_15180_41600.n4 a_15180_41600.t35 0.228
R2565 a_15180_41600.n6 a_15180_41600.t24 0.228
R2566 a_15180_41600.n6 a_15180_41600.t23 0.228
R2567 a_15180_41600.n8 a_15180_41600.t8 0.228
R2568 a_15180_41600.n8 a_15180_41600.t7 0.228
R2569 a_15180_41600.n10 a_15180_41600.t13 0.228
R2570 a_15180_41600.n10 a_15180_41600.t12 0.228
R2571 a_15180_41600.n12 a_15180_41600.t18 0.228
R2572 a_15180_41600.n12 a_15180_41600.t17 0.228
R2573 a_15180_41600.n14 a_15180_41600.t1 0.228
R2574 a_15180_41600.n14 a_15180_41600.t32 0.228
R2575 a_15180_41600.n16 a_15180_41600.t43 0.228
R2576 a_15180_41600.n16 a_15180_41600.t29 0.228
R2577 a_15180_41600.n18 a_15180_41600.t6 0.228
R2578 a_15180_41600.n18 a_15180_41600.t28 0.228
R2579 a_15180_41600.n20 a_15180_41600.t16 0.228
R2580 a_15180_41600.n20 a_15180_41600.t11 0.228
R2581 a_15180_41600.n145 a_15180_41600.t10 0.20525
R2582 a_15180_41600.n145 a_15180_41600.t9 0.20525
R2583 a_15180_41600.n147 a_15180_41600.t15 0.20525
R2584 a_15180_41600.n147 a_15180_41600.t14 0.20525
R2585 a_15180_41600.n149 a_15180_41600.t22 0.20525
R2586 a_15180_41600.n149 a_15180_41600.t21 0.20525
R2587 a_15180_41600.n151 a_15180_41600.t5 0.20525
R2588 a_15180_41600.n151 a_15180_41600.t4 0.20525
R2589 a_15180_41600.n153 a_15180_41600.t40 0.20525
R2590 a_15180_41600.n153 a_15180_41600.t39 0.20525
R2591 a_15180_41600.n155 a_15180_41600.t47 0.20525
R2592 a_15180_41600.n155 a_15180_41600.t46 0.20525
R2593 a_15180_41600.n157 a_15180_41600.t20 0.20525
R2594 a_15180_41600.n157 a_15180_41600.t19 0.20525
R2595 a_15180_41600.n159 a_15180_41600.t3 0.20525
R2596 a_15180_41600.n159 a_15180_41600.t2 0.20525
R2597 a_15180_41600.n161 a_15180_41600.t42 0.20525
R2598 a_15180_41600.n161 a_15180_41600.t41 0.20525
R2599 a_15180_41600.n163 a_15180_41600.t38 0.20525
R2600 a_15180_41600.n163 a_15180_41600.t37 0.20525
R2601 a_15180_41600.n165 a_15180_41600.t34 0.20525
R2602 a_15180_41600.n165 a_15180_41600.t33 0.20525
R2603 a_15180_41600.n169 a_15180_41600.n21 0.189974
R2604 a_15180_41600.n21 a_15180_41600.n19 0.189974
R2605 a_15180_41600.n19 a_15180_41600.n17 0.189974
R2606 a_15180_41600.n17 a_15180_41600.n15 0.189974
R2607 a_15180_41600.n15 a_15180_41600.n13 0.189974
R2608 a_15180_41600.n13 a_15180_41600.n11 0.189974
R2609 a_15180_41600.n11 a_15180_41600.n9 0.189974
R2610 a_15180_41600.n9 a_15180_41600.n7 0.189974
R2611 a_15180_41600.n7 a_15180_41600.n5 0.189974
R2612 a_15180_41600.n5 a_15180_41600.n3 0.189974
R2613 a_15180_41600.n3 a_15180_41600.n1 0.189974
R2614 a_15180_41600.n167 a_15180_41600.n166 0.189974
R2615 a_15180_41600.n166 a_15180_41600.n164 0.189974
R2616 a_15180_41600.n164 a_15180_41600.n162 0.189974
R2617 a_15180_41600.n162 a_15180_41600.n160 0.189974
R2618 a_15180_41600.n160 a_15180_41600.n158 0.189974
R2619 a_15180_41600.n158 a_15180_41600.n156 0.189974
R2620 a_15180_41600.n156 a_15180_41600.n154 0.189974
R2621 a_15180_41600.n154 a_15180_41600.n152 0.189974
R2622 a_15180_41600.n152 a_15180_41600.n150 0.189974
R2623 a_15180_41600.n150 a_15180_41600.n148 0.189974
R2624 a_15180_41600.n148 a_15180_41600.n146 0.189974
R2625 a_15180_41600.n138 a_15180_41600.n83 0.1205
R2626 a_15180_41600.n138 a_15180_41600.n137 0.1205
R2627 a_15180_41600.n137 a_15180_41600.n136 0.1205
R2628 a_15180_41600.n136 a_15180_41600.n113 0.1205
R2629 a_15180_41600.n132 a_15180_41600.n113 0.1205
R2630 a_15180_41600.n132 a_15180_41600.n131 0.1205
R2631 a_15180_41600.n131 a_15180_41600.n130 0.1205
R2632 a_15180_41600.n130 a_15180_41600.n115 0.1205
R2633 a_15180_41600.n126 a_15180_41600.n115 0.1205
R2634 a_15180_41600.n126 a_15180_41600.n125 0.1205
R2635 a_15180_41600.n125 a_15180_41600.n124 0.1205
R2636 a_15180_41600.n124 a_15180_41600.n117 0.1205
R2637 a_15180_41600.n120 a_15180_41600.n117 0.1205
R2638 a_15180_41600.n96 a_15180_41600.n95 0.1205
R2639 a_15180_41600.n95 a_15180_41600.n94 0.1205
R2640 a_15180_41600.n94 a_15180_41600.n93 0.1205
R2641 a_15180_41600.n93 a_15180_41600.n92 0.1205
R2642 a_15180_41600.n92 a_15180_41600.n91 0.1205
R2643 a_15180_41600.n91 a_15180_41600.n90 0.1205
R2644 a_15180_41600.n90 a_15180_41600.n89 0.1205
R2645 a_15180_41600.n89 a_15180_41600.n88 0.1205
R2646 a_15180_41600.n88 a_15180_41600.n87 0.1205
R2647 a_15180_41600.n87 a_15180_41600.n86 0.1205
R2648 a_15180_41600.n86 a_15180_41600.n85 0.1205
R2649 a_15180_41600.n85 a_15180_41600.n84 0.1205
R2650 a_15180_41600.n142 a_15180_41600.n84 0.1205
R2651 a_15180_41600.n77 a_15180_41600.n22 0.1205
R2652 a_15180_41600.n77 a_15180_41600.n76 0.1205
R2653 a_15180_41600.n76 a_15180_41600.n75 0.1205
R2654 a_15180_41600.n75 a_15180_41600.n52 0.1205
R2655 a_15180_41600.n71 a_15180_41600.n52 0.1205
R2656 a_15180_41600.n71 a_15180_41600.n70 0.1205
R2657 a_15180_41600.n70 a_15180_41600.n69 0.1205
R2658 a_15180_41600.n69 a_15180_41600.n54 0.1205
R2659 a_15180_41600.n65 a_15180_41600.n54 0.1205
R2660 a_15180_41600.n65 a_15180_41600.n64 0.1205
R2661 a_15180_41600.n64 a_15180_41600.n63 0.1205
R2662 a_15180_41600.n63 a_15180_41600.n56 0.1205
R2663 a_15180_41600.n59 a_15180_41600.n56 0.1205
R2664 a_15180_41600.n35 a_15180_41600.n34 0.1205
R2665 a_15180_41600.n34 a_15180_41600.n33 0.1205
R2666 a_15180_41600.n33 a_15180_41600.n32 0.1205
R2667 a_15180_41600.n32 a_15180_41600.n31 0.1205
R2668 a_15180_41600.n31 a_15180_41600.n30 0.1205
R2669 a_15180_41600.n30 a_15180_41600.n29 0.1205
R2670 a_15180_41600.n29 a_15180_41600.n28 0.1205
R2671 a_15180_41600.n28 a_15180_41600.n27 0.1205
R2672 a_15180_41600.n27 a_15180_41600.n26 0.1205
R2673 a_15180_41600.n26 a_15180_41600.n25 0.1205
R2674 a_15180_41600.n25 a_15180_41600.n24 0.1205
R2675 a_15180_41600.n24 a_15180_41600.n23 0.1205
R2676 a_15180_41600.n81 a_15180_41600.n23 0.1205
R2677 a_15180_41600.n143 a_15180_41600.n83 0.0485
R2678 a_15180_41600.n143 a_15180_41600.n142 0.0485
R2679 a_15180_41600.n82 a_15180_41600.n22 0.0485
R2680 a_15180_41600.n82 a_15180_41600.n81 0.0485
R2681 a_6924_41600.n55 a_6924_41600.t39 113.632
R2682 a_6924_41600.n71 a_6924_41600.t16 113.632
R2683 a_6924_41600.n10 a_6924_41600.t63 113.632
R2684 a_6924_41600.n26 a_6924_41600.t40 113.632
R2685 a_6924_41600.n86 a_6924_41600.t27 109.174
R2686 a_6924_41600.n87 a_6924_41600.t28 109.174
R2687 a_6924_41600.n56 a_6924_41600.t38 109.174
R2688 a_6924_41600.n57 a_6924_41600.t37 109.174
R2689 a_6924_41600.n58 a_6924_41600.t36 109.174
R2690 a_6924_41600.n59 a_6924_41600.t35 109.174
R2691 a_6924_41600.n60 a_6924_41600.t34 109.174
R2692 a_6924_41600.n61 a_6924_41600.t33 109.174
R2693 a_6924_41600.n62 a_6924_41600.t32 109.174
R2694 a_6924_41600.n63 a_6924_41600.t31 109.174
R2695 a_6924_41600.n64 a_6924_41600.t30 109.174
R2696 a_6924_41600.n65 a_6924_41600.t29 109.174
R2697 a_6924_41600.n85 a_6924_41600.t26 109.174
R2698 a_6924_41600.n66 a_6924_41600.t25 109.174
R2699 a_6924_41600.n81 a_6924_41600.t24 109.174
R2700 a_6924_41600.n80 a_6924_41600.t23 109.174
R2701 a_6924_41600.n79 a_6924_41600.t22 109.174
R2702 a_6924_41600.n68 a_6924_41600.t21 109.174
R2703 a_6924_41600.n75 a_6924_41600.t20 109.174
R2704 a_6924_41600.n74 a_6924_41600.t19 109.174
R2705 a_6924_41600.n73 a_6924_41600.t18 109.174
R2706 a_6924_41600.n70 a_6924_41600.t17 109.174
R2707 a_6924_41600.n41 a_6924_41600.t51 109.174
R2708 a_6924_41600.n42 a_6924_41600.t52 109.174
R2709 a_6924_41600.n11 a_6924_41600.t62 109.174
R2710 a_6924_41600.n12 a_6924_41600.t61 109.174
R2711 a_6924_41600.n13 a_6924_41600.t60 109.174
R2712 a_6924_41600.n14 a_6924_41600.t59 109.174
R2713 a_6924_41600.n15 a_6924_41600.t58 109.174
R2714 a_6924_41600.n16 a_6924_41600.t57 109.174
R2715 a_6924_41600.n17 a_6924_41600.t56 109.174
R2716 a_6924_41600.n18 a_6924_41600.t55 109.174
R2717 a_6924_41600.n19 a_6924_41600.t54 109.174
R2718 a_6924_41600.n20 a_6924_41600.t53 109.174
R2719 a_6924_41600.n40 a_6924_41600.t50 109.174
R2720 a_6924_41600.n21 a_6924_41600.t49 109.174
R2721 a_6924_41600.n36 a_6924_41600.t48 109.174
R2722 a_6924_41600.n35 a_6924_41600.t47 109.174
R2723 a_6924_41600.n34 a_6924_41600.t46 109.174
R2724 a_6924_41600.n23 a_6924_41600.t45 109.174
R2725 a_6924_41600.n30 a_6924_41600.t44 109.174
R2726 a_6924_41600.n29 a_6924_41600.t43 109.174
R2727 a_6924_41600.n28 a_6924_41600.t42 109.174
R2728 a_6924_41600.n25 a_6924_41600.t41 109.174
R2729 a_6924_41600.n98 a_6924_41600.n90 19.4712
R2730 a_6924_41600.n86 a_6924_41600.n45 18.4942
R2731 a_6924_41600.n88 a_6924_41600.n87 18.4942
R2732 a_6924_41600.n57 a_6924_41600.n54 18.4942
R2733 a_6924_41600.n58 a_6924_41600.n53 18.4942
R2734 a_6924_41600.n59 a_6924_41600.n52 18.4942
R2735 a_6924_41600.n60 a_6924_41600.n51 18.4942
R2736 a_6924_41600.n61 a_6924_41600.n50 18.4942
R2737 a_6924_41600.n62 a_6924_41600.n49 18.4942
R2738 a_6924_41600.n63 a_6924_41600.n48 18.4942
R2739 a_6924_41600.n64 a_6924_41600.n47 18.4942
R2740 a_6924_41600.n65 a_6924_41600.n46 18.4942
R2741 a_6924_41600.n85 a_6924_41600.n84 18.4942
R2742 a_6924_41600.n83 a_6924_41600.n66 18.4942
R2743 a_6924_41600.n82 a_6924_41600.n81 18.4942
R2744 a_6924_41600.n80 a_6924_41600.n67 18.4942
R2745 a_6924_41600.n79 a_6924_41600.n78 18.4942
R2746 a_6924_41600.n77 a_6924_41600.n68 18.4942
R2747 a_6924_41600.n76 a_6924_41600.n75 18.4942
R2748 a_6924_41600.n74 a_6924_41600.n69 18.4942
R2749 a_6924_41600.n73 a_6924_41600.n72 18.4942
R2750 a_6924_41600.n41 a_6924_41600.n0 18.4942
R2751 a_6924_41600.n43 a_6924_41600.n42 18.4942
R2752 a_6924_41600.n12 a_6924_41600.n9 18.4942
R2753 a_6924_41600.n13 a_6924_41600.n8 18.4942
R2754 a_6924_41600.n14 a_6924_41600.n7 18.4942
R2755 a_6924_41600.n15 a_6924_41600.n6 18.4942
R2756 a_6924_41600.n16 a_6924_41600.n5 18.4942
R2757 a_6924_41600.n17 a_6924_41600.n4 18.4942
R2758 a_6924_41600.n18 a_6924_41600.n3 18.4942
R2759 a_6924_41600.n19 a_6924_41600.n2 18.4942
R2760 a_6924_41600.n20 a_6924_41600.n1 18.4942
R2761 a_6924_41600.n40 a_6924_41600.n39 18.4942
R2762 a_6924_41600.n38 a_6924_41600.n21 18.4942
R2763 a_6924_41600.n37 a_6924_41600.n36 18.4942
R2764 a_6924_41600.n35 a_6924_41600.n22 18.4942
R2765 a_6924_41600.n34 a_6924_41600.n33 18.4942
R2766 a_6924_41600.n32 a_6924_41600.n23 18.4942
R2767 a_6924_41600.n31 a_6924_41600.n30 18.4942
R2768 a_6924_41600.n29 a_6924_41600.n24 18.4942
R2769 a_6924_41600.n28 a_6924_41600.n27 18.4942
R2770 a_6924_41600.n86 a_6924_41600.n85 11.6805
R2771 a_6924_41600.n87 a_6924_41600.n86 11.6805
R2772 a_6924_41600.n57 a_6924_41600.n56 11.6805
R2773 a_6924_41600.n58 a_6924_41600.n57 11.6805
R2774 a_6924_41600.n59 a_6924_41600.n58 11.6805
R2775 a_6924_41600.n60 a_6924_41600.n59 11.6805
R2776 a_6924_41600.n61 a_6924_41600.n60 11.6805
R2777 a_6924_41600.n62 a_6924_41600.n61 11.6805
R2778 a_6924_41600.n63 a_6924_41600.n62 11.6805
R2779 a_6924_41600.n64 a_6924_41600.n63 11.6805
R2780 a_6924_41600.n65 a_6924_41600.n64 11.6805
R2781 a_6924_41600.n87 a_6924_41600.n65 11.6805
R2782 a_6924_41600.n85 a_6924_41600.n66 11.6805
R2783 a_6924_41600.n81 a_6924_41600.n66 11.6805
R2784 a_6924_41600.n81 a_6924_41600.n80 11.6805
R2785 a_6924_41600.n80 a_6924_41600.n79 11.6805
R2786 a_6924_41600.n79 a_6924_41600.n68 11.6805
R2787 a_6924_41600.n75 a_6924_41600.n68 11.6805
R2788 a_6924_41600.n75 a_6924_41600.n74 11.6805
R2789 a_6924_41600.n74 a_6924_41600.n73 11.6805
R2790 a_6924_41600.n73 a_6924_41600.n70 11.6805
R2791 a_6924_41600.n41 a_6924_41600.n40 11.6805
R2792 a_6924_41600.n42 a_6924_41600.n41 11.6805
R2793 a_6924_41600.n12 a_6924_41600.n11 11.6805
R2794 a_6924_41600.n13 a_6924_41600.n12 11.6805
R2795 a_6924_41600.n14 a_6924_41600.n13 11.6805
R2796 a_6924_41600.n15 a_6924_41600.n14 11.6805
R2797 a_6924_41600.n16 a_6924_41600.n15 11.6805
R2798 a_6924_41600.n17 a_6924_41600.n16 11.6805
R2799 a_6924_41600.n18 a_6924_41600.n17 11.6805
R2800 a_6924_41600.n19 a_6924_41600.n18 11.6805
R2801 a_6924_41600.n20 a_6924_41600.n19 11.6805
R2802 a_6924_41600.n42 a_6924_41600.n20 11.6805
R2803 a_6924_41600.n40 a_6924_41600.n21 11.6805
R2804 a_6924_41600.n36 a_6924_41600.n21 11.6805
R2805 a_6924_41600.n36 a_6924_41600.n35 11.6805
R2806 a_6924_41600.n35 a_6924_41600.n34 11.6805
R2807 a_6924_41600.n34 a_6924_41600.n23 11.6805
R2808 a_6924_41600.n30 a_6924_41600.n23 11.6805
R2809 a_6924_41600.n30 a_6924_41600.n29 11.6805
R2810 a_6924_41600.n29 a_6924_41600.n28 11.6805
R2811 a_6924_41600.n28 a_6924_41600.n25 11.6805
R2812 a_6924_41600.n90 a_6924_41600.n44 10.013
R2813 a_6924_41600.n90 a_6924_41600.n89 9.91657
R2814 a_6924_41600.n72 a_6924_41600.n71 7.17687
R2815 a_6924_41600.n55 a_6924_41600.n54 7.17687
R2816 a_6924_41600.n27 a_6924_41600.n26 7.17687
R2817 a_6924_41600.n10 a_6924_41600.n9 7.17687
R2818 a_6924_41600.n99 a_6924_41600.n98 6.5392
R2819 a_6924_41600.n92 a_6924_41600.t15 5.7796
R2820 a_6924_41600.t7 a_6924_41600.n105 5.73764
R2821 a_6924_41600.n97 a_6924_41600.t8 5.59012
R2822 a_6924_41600.n99 a_6924_41600.t0 5.54817
R2823 a_6924_41600.n92 a_6924_41600.n91 5.38537
R2824 a_6924_41600.n94 a_6924_41600.n93 5.38537
R2825 a_6924_41600.n96 a_6924_41600.n95 5.38537
R2826 a_6924_41600.n105 a_6924_41600.n104 5.32067
R2827 a_6924_41600.n103 a_6924_41600.n102 5.32067
R2828 a_6924_41600.n101 a_6924_41600.n100 5.32067
R2829 a_6924_41600.n98 a_6924_41600.n97 4.61063
R2830 a_6924_41600.n56 a_6924_41600.n55 4.42851
R2831 a_6924_41600.n71 a_6924_41600.n70 4.42851
R2832 a_6924_41600.n11 a_6924_41600.n10 4.42851
R2833 a_6924_41600.n26 a_6924_41600.n25 4.42851
R2834 a_6924_41600.n104 a_6924_41600.t5 0.228
R2835 a_6924_41600.n104 a_6924_41600.t6 0.228
R2836 a_6924_41600.n102 a_6924_41600.t3 0.228
R2837 a_6924_41600.n102 a_6924_41600.t4 0.228
R2838 a_6924_41600.n100 a_6924_41600.t1 0.228
R2839 a_6924_41600.n100 a_6924_41600.t2 0.228
R2840 a_6924_41600.n91 a_6924_41600.t13 0.20525
R2841 a_6924_41600.n91 a_6924_41600.t14 0.20525
R2842 a_6924_41600.n93 a_6924_41600.t11 0.20525
R2843 a_6924_41600.n93 a_6924_41600.t12 0.20525
R2844 a_6924_41600.n95 a_6924_41600.t9 0.20525
R2845 a_6924_41600.n95 a_6924_41600.t10 0.20525
R2846 a_6924_41600.n101 a_6924_41600.n99 0.189974
R2847 a_6924_41600.n103 a_6924_41600.n101 0.189974
R2848 a_6924_41600.n105 a_6924_41600.n103 0.189974
R2849 a_6924_41600.n97 a_6924_41600.n96 0.189974
R2850 a_6924_41600.n96 a_6924_41600.n94 0.189974
R2851 a_6924_41600.n94 a_6924_41600.n92 0.189974
R2852 a_6924_41600.n84 a_6924_41600.n45 0.1205
R2853 a_6924_41600.n84 a_6924_41600.n83 0.1205
R2854 a_6924_41600.n83 a_6924_41600.n82 0.1205
R2855 a_6924_41600.n82 a_6924_41600.n67 0.1205
R2856 a_6924_41600.n78 a_6924_41600.n67 0.1205
R2857 a_6924_41600.n78 a_6924_41600.n77 0.1205
R2858 a_6924_41600.n77 a_6924_41600.n76 0.1205
R2859 a_6924_41600.n76 a_6924_41600.n69 0.1205
R2860 a_6924_41600.n72 a_6924_41600.n69 0.1205
R2861 a_6924_41600.n54 a_6924_41600.n53 0.1205
R2862 a_6924_41600.n53 a_6924_41600.n52 0.1205
R2863 a_6924_41600.n52 a_6924_41600.n51 0.1205
R2864 a_6924_41600.n51 a_6924_41600.n50 0.1205
R2865 a_6924_41600.n50 a_6924_41600.n49 0.1205
R2866 a_6924_41600.n49 a_6924_41600.n48 0.1205
R2867 a_6924_41600.n48 a_6924_41600.n47 0.1205
R2868 a_6924_41600.n47 a_6924_41600.n46 0.1205
R2869 a_6924_41600.n88 a_6924_41600.n46 0.1205
R2870 a_6924_41600.n39 a_6924_41600.n0 0.1205
R2871 a_6924_41600.n39 a_6924_41600.n38 0.1205
R2872 a_6924_41600.n38 a_6924_41600.n37 0.1205
R2873 a_6924_41600.n37 a_6924_41600.n22 0.1205
R2874 a_6924_41600.n33 a_6924_41600.n22 0.1205
R2875 a_6924_41600.n33 a_6924_41600.n32 0.1205
R2876 a_6924_41600.n32 a_6924_41600.n31 0.1205
R2877 a_6924_41600.n31 a_6924_41600.n24 0.1205
R2878 a_6924_41600.n27 a_6924_41600.n24 0.1205
R2879 a_6924_41600.n9 a_6924_41600.n8 0.1205
R2880 a_6924_41600.n8 a_6924_41600.n7 0.1205
R2881 a_6924_41600.n7 a_6924_41600.n6 0.1205
R2882 a_6924_41600.n6 a_6924_41600.n5 0.1205
R2883 a_6924_41600.n5 a_6924_41600.n4 0.1205
R2884 a_6924_41600.n4 a_6924_41600.n3 0.1205
R2885 a_6924_41600.n3 a_6924_41600.n2 0.1205
R2886 a_6924_41600.n2 a_6924_41600.n1 0.1205
R2887 a_6924_41600.n43 a_6924_41600.n1 0.1205
R2888 a_6924_41600.n89 a_6924_41600.n45 0.0485
R2889 a_6924_41600.n89 a_6924_41600.n88 0.0485
R2890 a_6924_41600.n44 a_6924_41600.n0 0.0485
R2891 a_6924_41600.n44 a_6924_41600.n43 0.0485
R2892 a_4812_41600.n15 a_4812_41600.t15 113.632
R2893 a_4812_41600.n19 a_4812_41600.t8 113.632
R2894 a_4812_41600.n2 a_4812_41600.t23 113.632
R2895 a_4812_41600.n6 a_4812_41600.t16 113.632
R2896 a_4812_41600.n22 a_4812_41600.t11 109.174
R2897 a_4812_41600.n23 a_4812_41600.t12 109.174
R2898 a_4812_41600.n16 a_4812_41600.t14 109.174
R2899 a_4812_41600.n17 a_4812_41600.t13 109.174
R2900 a_4812_41600.n21 a_4812_41600.t10 109.174
R2901 a_4812_41600.n18 a_4812_41600.t9 109.174
R2902 a_4812_41600.n9 a_4812_41600.t19 109.174
R2903 a_4812_41600.n10 a_4812_41600.t20 109.174
R2904 a_4812_41600.n3 a_4812_41600.t22 109.174
R2905 a_4812_41600.n4 a_4812_41600.t21 109.174
R2906 a_4812_41600.n8 a_4812_41600.t18 109.174
R2907 a_4812_41600.n5 a_4812_41600.t17 109.174
R2908 a_4812_41600.n22 a_4812_41600.n13 18.4942
R2909 a_4812_41600.n24 a_4812_41600.n23 18.4942
R2910 a_4812_41600.n17 a_4812_41600.n14 18.4942
R2911 a_4812_41600.n21 a_4812_41600.n20 18.4942
R2912 a_4812_41600.n9 a_4812_41600.n0 18.4942
R2913 a_4812_41600.n11 a_4812_41600.n10 18.4942
R2914 a_4812_41600.n4 a_4812_41600.n1 18.4942
R2915 a_4812_41600.n8 a_4812_41600.n7 18.4942
R2916 a_4812_41600.n30 a_4812_41600.n26 17.9305
R2917 a_4812_41600.n22 a_4812_41600.n21 11.6805
R2918 a_4812_41600.n23 a_4812_41600.n22 11.6805
R2919 a_4812_41600.n17 a_4812_41600.n16 11.6805
R2920 a_4812_41600.n23 a_4812_41600.n17 11.6805
R2921 a_4812_41600.n21 a_4812_41600.n18 11.6805
R2922 a_4812_41600.n9 a_4812_41600.n8 11.6805
R2923 a_4812_41600.n10 a_4812_41600.n9 11.6805
R2924 a_4812_41600.n4 a_4812_41600.n3 11.6805
R2925 a_4812_41600.n10 a_4812_41600.n4 11.6805
R2926 a_4812_41600.n8 a_4812_41600.n5 11.6805
R2927 a_4812_41600.n26 a_4812_41600.n12 10.3505
R2928 a_4812_41600.n26 a_4812_41600.n25 9.57907
R2929 a_4812_41600.n20 a_4812_41600.n19 7.17687
R2930 a_4812_41600.n15 a_4812_41600.n14 7.17687
R2931 a_4812_41600.n7 a_4812_41600.n6 7.17687
R2932 a_4812_41600.n2 a_4812_41600.n1 7.17687
R2933 a_4812_41600.n31 a_4812_41600.n30 6.5392
R2934 a_4812_41600.n28 a_4812_41600.t7 5.7796
R2935 a_4812_41600.t3 a_4812_41600.n33 5.73764
R2936 a_4812_41600.n29 a_4812_41600.t4 5.59012
R2937 a_4812_41600.n31 a_4812_41600.t0 5.54817
R2938 a_4812_41600.n28 a_4812_41600.n27 5.38537
R2939 a_4812_41600.n33 a_4812_41600.n32 5.32067
R2940 a_4812_41600.n30 a_4812_41600.n29 4.61063
R2941 a_4812_41600.n16 a_4812_41600.n15 4.42851
R2942 a_4812_41600.n19 a_4812_41600.n18 4.42851
R2943 a_4812_41600.n3 a_4812_41600.n2 4.42851
R2944 a_4812_41600.n6 a_4812_41600.n5 4.42851
R2945 a_4812_41600.n32 a_4812_41600.t1 0.228
R2946 a_4812_41600.n32 a_4812_41600.t2 0.228
R2947 a_4812_41600.n27 a_4812_41600.t5 0.20525
R2948 a_4812_41600.n27 a_4812_41600.t6 0.20525
R2949 a_4812_41600.n33 a_4812_41600.n31 0.189974
R2950 a_4812_41600.n29 a_4812_41600.n28 0.189974
R2951 a_4812_41600.n20 a_4812_41600.n13 0.1205
R2952 a_4812_41600.n24 a_4812_41600.n14 0.1205
R2953 a_4812_41600.n7 a_4812_41600.n0 0.1205
R2954 a_4812_41600.n11 a_4812_41600.n1 0.1205
R2955 a_4812_41600.n25 a_4812_41600.n13 0.0485
R2956 a_4812_41600.n25 a_4812_41600.n24 0.0485
R2957 a_4812_41600.n12 a_4812_41600.n0 0.0485
R2958 a_4812_41600.n12 a_4812_41600.n11 0.0485
R2959 a_2700_41600.n15 a_2700_41600.t15 113.632
R2960 a_2700_41600.n19 a_2700_41600.t8 113.632
R2961 a_2700_41600.n2 a_2700_41600.t23 113.632
R2962 a_2700_41600.n6 a_2700_41600.t16 113.632
R2963 a_2700_41600.n22 a_2700_41600.t11 109.174
R2964 a_2700_41600.n23 a_2700_41600.t12 109.174
R2965 a_2700_41600.n16 a_2700_41600.t14 109.174
R2966 a_2700_41600.n17 a_2700_41600.t13 109.174
R2967 a_2700_41600.n21 a_2700_41600.t10 109.174
R2968 a_2700_41600.n18 a_2700_41600.t9 109.174
R2969 a_2700_41600.n9 a_2700_41600.t19 109.174
R2970 a_2700_41600.n10 a_2700_41600.t20 109.174
R2971 a_2700_41600.n3 a_2700_41600.t22 109.174
R2972 a_2700_41600.n4 a_2700_41600.t21 109.174
R2973 a_2700_41600.n8 a_2700_41600.t18 109.174
R2974 a_2700_41600.n5 a_2700_41600.t17 109.174
R2975 a_2700_41600.n22 a_2700_41600.n13 18.4942
R2976 a_2700_41600.n24 a_2700_41600.n23 18.4942
R2977 a_2700_41600.n17 a_2700_41600.n14 18.4942
R2978 a_2700_41600.n21 a_2700_41600.n20 18.4942
R2979 a_2700_41600.n9 a_2700_41600.n0 18.4942
R2980 a_2700_41600.n11 a_2700_41600.n10 18.4942
R2981 a_2700_41600.n4 a_2700_41600.n1 18.4942
R2982 a_2700_41600.n8 a_2700_41600.n7 18.4942
R2983 a_2700_41600.n30 a_2700_41600.n26 17.6419
R2984 a_2700_41600.n22 a_2700_41600.n21 11.6805
R2985 a_2700_41600.n23 a_2700_41600.n22 11.6805
R2986 a_2700_41600.n17 a_2700_41600.n16 11.6805
R2987 a_2700_41600.n23 a_2700_41600.n17 11.6805
R2988 a_2700_41600.n21 a_2700_41600.n18 11.6805
R2989 a_2700_41600.n9 a_2700_41600.n8 11.6805
R2990 a_2700_41600.n10 a_2700_41600.n9 11.6805
R2991 a_2700_41600.n4 a_2700_41600.n3 11.6805
R2992 a_2700_41600.n10 a_2700_41600.n4 11.6805
R2993 a_2700_41600.n8 a_2700_41600.n5 11.6805
R2994 a_2700_41600.n26 a_2700_41600.n12 10.688
R2995 a_2700_41600.n26 a_2700_41600.n25 9.24157
R2996 a_2700_41600.n20 a_2700_41600.n19 7.17687
R2997 a_2700_41600.n15 a_2700_41600.n14 7.17687
R2998 a_2700_41600.n7 a_2700_41600.n6 7.17687
R2999 a_2700_41600.n2 a_2700_41600.n1 7.17687
R3000 a_2700_41600.n31 a_2700_41600.n30 6.5392
R3001 a_2700_41600.n28 a_2700_41600.t7 5.7796
R3002 a_2700_41600.t3 a_2700_41600.n33 5.73764
R3003 a_2700_41600.n29 a_2700_41600.t4 5.59012
R3004 a_2700_41600.n31 a_2700_41600.t0 5.54817
R3005 a_2700_41600.n28 a_2700_41600.n27 5.38537
R3006 a_2700_41600.n33 a_2700_41600.n32 5.32067
R3007 a_2700_41600.n30 a_2700_41600.n29 4.61063
R3008 a_2700_41600.n16 a_2700_41600.n15 4.42851
R3009 a_2700_41600.n19 a_2700_41600.n18 4.42851
R3010 a_2700_41600.n3 a_2700_41600.n2 4.42851
R3011 a_2700_41600.n6 a_2700_41600.n5 4.42851
R3012 a_2700_41600.n32 a_2700_41600.t1 0.228
R3013 a_2700_41600.n32 a_2700_41600.t2 0.228
R3014 a_2700_41600.n27 a_2700_41600.t5 0.20525
R3015 a_2700_41600.n27 a_2700_41600.t6 0.20525
R3016 a_2700_41600.n33 a_2700_41600.n31 0.189974
R3017 a_2700_41600.n29 a_2700_41600.n28 0.189974
R3018 a_2700_41600.n20 a_2700_41600.n13 0.1205
R3019 a_2700_41600.n24 a_2700_41600.n14 0.1205
R3020 a_2700_41600.n7 a_2700_41600.n0 0.1205
R3021 a_2700_41600.n11 a_2700_41600.n1 0.1205
R3022 a_2700_41600.n25 a_2700_41600.n13 0.0485
R3023 a_2700_41600.n25 a_2700_41600.n24 0.0485
R3024 a_2700_41600.n12 a_2700_41600.n0 0.0485
R3025 a_2700_41600.n12 a_2700_41600.n11 0.0485
C0 CLKP_HB CLKP_H 0.13381f
C1 VDD O_SENSE 40.93f
C2 VDD O_CAPTURE_CLK 11.2502f
C3 VDD CLKP_H 2.64315f
C4 VDD CLKN_HB 4.51557f
C5 VDD O_CAPTURE_CLKB 11.3088f
C6 CLKN_HB CLKN_H 0.13381f
C7 E_CAPTURE_CLKB E_CAPTURE_CLK 0.13895f
C8 VDD E_SENSE 40.93f
C9 VDD E_CAPTURE_CLK 11.2502f
C10 VDD E_CAPTURE_CLKB 11.3088f
C11 VDD CLKP_HB 4.51557f
C12 O_CAPTURE_CLKB O_CAPTURE_CLK 0.13895f
C13 VDD CLKN_H 2.64315f
C14 E_SENSE VSS 45.75606f
C15 E_CAPTURE_CLK VSS 13.22105f
C16 E_CAPTURE_CLKB VSS 11.56589f
C17 CLKP_H VSS 8.80759f
C18 CLKP_HB VSS 12.49212f
C19 O_SENSE VSS 45.75606f
C20 O_CAPTURE_CLK VSS 13.22105f
C21 O_CAPTURE_CLKB VSS 11.56589f
C22 CLKN_H VSS 8.80759f
C23 CLKN_HB VSS 12.96235f
C24 VDD VSS 2.66711p
C25 a_2700_41600.n0 VSS 0.0539f
C26 a_2700_41600.n1 VSS 0.1862f
C27 a_2700_41600.n2 VSS 0.09204f
C28 a_2700_41600.n3 VSS 0.09865f
C29 a_2700_41600.n4 VSS 0.09865f
C30 a_2700_41600.n5 VSS 0.09865f
C31 a_2700_41600.n6 VSS 0.09204f
C32 a_2700_41600.n7 VSS 0.1862f
C33 a_2700_41600.n8 VSS 0.09865f
C34 a_2700_41600.n9 VSS 0.09865f
C35 a_2700_41600.n10 VSS 0.09865f
C36 a_2700_41600.n11 VSS 0.0539f
C37 a_2700_41600.n12 VSS 0.30259f
C38 a_2700_41600.n13 VSS 0.0539f
C39 a_2700_41600.n14 VSS 0.1862f
C40 a_2700_41600.n15 VSS 0.09204f
C41 a_2700_41600.n16 VSS 0.09865f
C42 a_2700_41600.n17 VSS 0.09865f
C43 a_2700_41600.n18 VSS 0.09865f
C44 a_2700_41600.n19 VSS 0.09204f
C45 a_2700_41600.n20 VSS 0.1862f
C46 a_2700_41600.n21 VSS 0.09865f
C47 a_2700_41600.n22 VSS 0.09865f
C48 a_2700_41600.n23 VSS 0.09865f
C49 a_2700_41600.n24 VSS 0.0539f
C50 a_2700_41600.n25 VSS 0.22663f
C51 a_2700_41600.n26 VSS 2.11369f
C52 a_2700_41600.t7 VSS 0.78884f
C53 a_2700_41600.t6 VSS 0.18294f
C54 a_2700_41600.t5 VSS 0.18294f
C55 a_2700_41600.n27 VSS 0.57877f
C56 a_2700_41600.n28 VSS 0.32618f
C57 a_2700_41600.t4 VSS 0.7836f
C58 a_2700_41600.n29 VSS 0.23471f
C59 a_2700_41600.n30 VSS 1.96684f
C60 a_2700_41600.t0 VSS 0.785f
C61 a_2700_41600.n31 VSS 0.34615f
C62 a_2700_41600.t2 VSS 0.18294f
C63 a_2700_41600.t1 VSS 0.18294f
C64 a_2700_41600.n32 VSS 0.58307f
C65 a_2700_41600.n33 VSS 0.32049f
C66 a_2700_41600.t3 VSS 0.79023f
C67 a_4812_41600.n0 VSS 0.05635f
C68 a_4812_41600.n1 VSS 0.19467f
C69 a_4812_41600.n2 VSS 0.09622f
C70 a_4812_41600.n3 VSS 0.10314f
C71 a_4812_41600.n4 VSS 0.10314f
C72 a_4812_41600.n5 VSS 0.10314f
C73 a_4812_41600.n6 VSS 0.09622f
C74 a_4812_41600.n7 VSS 0.19467f
C75 a_4812_41600.n8 VSS 0.10314f
C76 a_4812_41600.n9 VSS 0.10314f
C77 a_4812_41600.n10 VSS 0.10314f
C78 a_4812_41600.n11 VSS 0.05635f
C79 a_4812_41600.n12 VSS 0.29267f
C80 a_4812_41600.n13 VSS 0.05635f
C81 a_4812_41600.n14 VSS 0.19467f
C82 a_4812_41600.n15 VSS 0.09622f
C83 a_4812_41600.n16 VSS 0.10314f
C84 a_4812_41600.n17 VSS 0.10314f
C85 a_4812_41600.n18 VSS 0.10314f
C86 a_4812_41600.n19 VSS 0.09622f
C87 a_4812_41600.n20 VSS 0.19467f
C88 a_4812_41600.n21 VSS 0.10314f
C89 a_4812_41600.n22 VSS 0.10314f
C90 a_4812_41600.n23 VSS 0.10314f
C91 a_4812_41600.n24 VSS 0.05635f
C92 a_4812_41600.n25 VSS 0.24991f
C93 a_4812_41600.n26 VSS 2.27959f
C94 a_4812_41600.t7 VSS 0.81015f
C95 a_4812_41600.t6 VSS 0.17696f
C96 a_4812_41600.t5 VSS 0.17696f
C97 a_4812_41600.n27 VSS 0.6051f
C98 a_4812_41600.n28 VSS 0.34102f
C99 a_4812_41600.t4 VSS 0.80467f
C100 a_4812_41600.n29 VSS 0.24539f
C101 a_4812_41600.n30 VSS 2.03081f
C102 a_4812_41600.t0 VSS 0.80613f
C103 a_4812_41600.n31 VSS 0.3619f
C104 a_4812_41600.t2 VSS 0.17696f
C105 a_4812_41600.t1 VSS 0.17696f
C106 a_4812_41600.n32 VSS 0.60959f
C107 a_4812_41600.n33 VSS 0.33507f
C108 a_4812_41600.t3 VSS 0.8116f
C109 a_6924_41600.n0 VSS 0.05175f
C110 a_6924_41600.n1 VSS 0.06142f
C111 a_6924_41600.n2 VSS 0.06142f
C112 a_6924_41600.n3 VSS 0.06142f
C113 a_6924_41600.n4 VSS 0.06142f
C114 a_6924_41600.n5 VSS 0.06142f
C115 a_6924_41600.n6 VSS 0.06142f
C116 a_6924_41600.n7 VSS 0.06142f
C117 a_6924_41600.n8 VSS 0.06142f
C118 a_6924_41600.n9 VSS 0.17878f
C119 a_6924_41600.n10 VSS 0.08837f
C120 a_6924_41600.n11 VSS 0.09472f
C121 a_6924_41600.n12 VSS 0.09472f
C122 a_6924_41600.n13 VSS 0.09472f
C123 a_6924_41600.n14 VSS 0.09472f
C124 a_6924_41600.n15 VSS 0.09472f
C125 a_6924_41600.n16 VSS 0.09472f
C126 a_6924_41600.n17 VSS 0.09472f
C127 a_6924_41600.n18 VSS 0.09472f
C128 a_6924_41600.n19 VSS 0.09472f
C129 a_6924_41600.n20 VSS 0.09472f
C130 a_6924_41600.n21 VSS 0.09472f
C131 a_6924_41600.n22 VSS 0.06142f
C132 a_6924_41600.n23 VSS 0.09472f
C133 a_6924_41600.n24 VSS 0.06142f
C134 a_6924_41600.n25 VSS 0.09472f
C135 a_6924_41600.n26 VSS 0.08837f
C136 a_6924_41600.n27 VSS 0.17878f
C137 a_6924_41600.n28 VSS 0.09472f
C138 a_6924_41600.n29 VSS 0.09472f
C139 a_6924_41600.n30 VSS 0.09472f
C140 a_6924_41600.n31 VSS 0.06142f
C141 a_6924_41600.n32 VSS 0.06142f
C142 a_6924_41600.n33 VSS 0.06142f
C143 a_6924_41600.n34 VSS 0.09472f
C144 a_6924_41600.n35 VSS 0.09472f
C145 a_6924_41600.n36 VSS 0.09472f
C146 a_6924_41600.n37 VSS 0.06142f
C147 a_6924_41600.n38 VSS 0.06142f
C148 a_6924_41600.n39 VSS 0.06142f
C149 a_6924_41600.n40 VSS 0.09472f
C150 a_6924_41600.n41 VSS 0.09472f
C151 a_6924_41600.n42 VSS 0.09472f
C152 a_6924_41600.n43 VSS 0.05175f
C153 a_6924_41600.n44 VSS 0.66009f
C154 a_6924_41600.n45 VSS 0.05175f
C155 a_6924_41600.n46 VSS 0.06142f
C156 a_6924_41600.n47 VSS 0.06142f
C157 a_6924_41600.n48 VSS 0.06142f
C158 a_6924_41600.n49 VSS 0.06142f
C159 a_6924_41600.n50 VSS 0.06142f
C160 a_6924_41600.n51 VSS 0.06142f
C161 a_6924_41600.n52 VSS 0.06142f
C162 a_6924_41600.n53 VSS 0.06142f
C163 a_6924_41600.n54 VSS 0.17878f
C164 a_6924_41600.n55 VSS 0.08837f
C165 a_6924_41600.n56 VSS 0.09472f
C166 a_6924_41600.n57 VSS 0.09472f
C167 a_6924_41600.n58 VSS 0.09472f
C168 a_6924_41600.n59 VSS 0.09472f
C169 a_6924_41600.n60 VSS 0.09472f
C170 a_6924_41600.n61 VSS 0.09472f
C171 a_6924_41600.n62 VSS 0.09472f
C172 a_6924_41600.n63 VSS 0.09472f
C173 a_6924_41600.n64 VSS 0.09472f
C174 a_6924_41600.n65 VSS 0.09472f
C175 a_6924_41600.n66 VSS 0.09472f
C176 a_6924_41600.n67 VSS 0.06142f
C177 a_6924_41600.n68 VSS 0.09472f
C178 a_6924_41600.n69 VSS 0.06142f
C179 a_6924_41600.n70 VSS 0.09472f
C180 a_6924_41600.n71 VSS 0.08837f
C181 a_6924_41600.n72 VSS 0.17878f
C182 a_6924_41600.n73 VSS 0.09472f
C183 a_6924_41600.n74 VSS 0.09472f
C184 a_6924_41600.n75 VSS 0.09472f
C185 a_6924_41600.n76 VSS 0.06142f
C186 a_6924_41600.n77 VSS 0.06142f
C187 a_6924_41600.n78 VSS 0.06142f
C188 a_6924_41600.n79 VSS 0.09472f
C189 a_6924_41600.n80 VSS 0.09472f
C190 a_6924_41600.n81 VSS 0.09472f
C191 a_6924_41600.n82 VSS 0.06142f
C192 a_6924_41600.n83 VSS 0.06142f
C193 a_6924_41600.n84 VSS 0.06142f
C194 a_6924_41600.n85 VSS 0.09472f
C195 a_6924_41600.n86 VSS 0.09472f
C196 a_6924_41600.n87 VSS 0.09472f
C197 a_6924_41600.n88 VSS 0.05175f
C198 a_6924_41600.n89 VSS 0.6519f
C199 a_6924_41600.n90 VSS 2.97932f
C200 a_6924_41600.t15 VSS 0.76025f
C201 a_6924_41600.t14 VSS 0.17845f
C202 a_6924_41600.t13 VSS 0.17845f
C203 a_6924_41600.n91 VSS 0.55569f
C204 a_6924_41600.n92 VSS 0.31318f
C205 a_6924_41600.t12 VSS 0.17845f
C206 a_6924_41600.t11 VSS 0.17845f
C207 a_6924_41600.n93 VSS 0.55569f
C208 a_6924_41600.n94 VSS 0.16476f
C209 a_6924_41600.t10 VSS 0.17845f
C210 a_6924_41600.t9 VSS 0.17845f
C211 a_6924_41600.n95 VSS 0.55569f
C212 a_6924_41600.n96 VSS 0.16476f
C213 a_6924_41600.t8 VSS 0.75521f
C214 a_6924_41600.n97 VSS 0.22535f
C215 a_6924_41600.n98 VSS 1.99322f
C216 a_6924_41600.t0 VSS 0.75656f
C217 a_6924_41600.n99 VSS 0.33235f
C218 a_6924_41600.t2 VSS 0.17845f
C219 a_6924_41600.t1 VSS 0.17845f
C220 a_6924_41600.n100 VSS 0.55982f
C221 a_6924_41600.n101 VSS 0.16064f
C222 a_6924_41600.t4 VSS 0.17845f
C223 a_6924_41600.t3 VSS 0.17845f
C224 a_6924_41600.n102 VSS 0.55982f
C225 a_6924_41600.n103 VSS 0.16064f
C226 a_6924_41600.t6 VSS 0.17845f
C227 a_6924_41600.t5 VSS 0.17845f
C228 a_6924_41600.n104 VSS 0.55982f
C229 a_6924_41600.n105 VSS 0.30772f
C230 a_6924_41600.t7 VSS 0.76158f
C231 a_15180_41600.t31 VSS 0.85941f
C232 a_15180_41600.t44 VSS 0.21197f
C233 a_15180_41600.t45 VSS 0.21197f
C234 a_15180_41600.n0 VSS 0.62131f
C235 a_15180_41600.n1 VSS 0.34152f
C236 a_15180_41600.t25 VSS 0.21197f
C237 a_15180_41600.t26 VSS 0.21197f
C238 a_15180_41600.n2 VSS 0.62131f
C239 a_15180_41600.n3 VSS 0.17828f
C240 a_15180_41600.t35 VSS 0.21197f
C241 a_15180_41600.t36 VSS 0.21197f
C242 a_15180_41600.n4 VSS 0.62131f
C243 a_15180_41600.n5 VSS 0.17828f
C244 a_15180_41600.t23 VSS 0.21197f
C245 a_15180_41600.t24 VSS 0.21197f
C246 a_15180_41600.n6 VSS 0.62131f
C247 a_15180_41600.n7 VSS 0.17828f
C248 a_15180_41600.t7 VSS 0.21197f
C249 a_15180_41600.t8 VSS 0.21197f
C250 a_15180_41600.n8 VSS 0.62131f
C251 a_15180_41600.n9 VSS 0.17828f
C252 a_15180_41600.t12 VSS 0.21197f
C253 a_15180_41600.t13 VSS 0.21197f
C254 a_15180_41600.n10 VSS 0.62131f
C255 a_15180_41600.n11 VSS 0.17828f
C256 a_15180_41600.t17 VSS 0.21197f
C257 a_15180_41600.t18 VSS 0.21197f
C258 a_15180_41600.n12 VSS 0.62131f
C259 a_15180_41600.n13 VSS 0.17828f
C260 a_15180_41600.t32 VSS 0.21197f
C261 a_15180_41600.t1 VSS 0.21197f
C262 a_15180_41600.n14 VSS 0.62131f
C263 a_15180_41600.n15 VSS 0.17828f
C264 a_15180_41600.t29 VSS 0.21197f
C265 a_15180_41600.t43 VSS 0.21197f
C266 a_15180_41600.n16 VSS 0.62131f
C267 a_15180_41600.n17 VSS 0.17828f
C268 a_15180_41600.t28 VSS 0.21197f
C269 a_15180_41600.t6 VSS 0.21197f
C270 a_15180_41600.n18 VSS 0.62131f
C271 a_15180_41600.n19 VSS 0.17828f
C272 a_15180_41600.t11 VSS 0.21197f
C273 a_15180_41600.t16 VSS 0.21197f
C274 a_15180_41600.n20 VSS 0.62131f
C275 a_15180_41600.n21 VSS 0.17828f
C276 a_15180_41600.n22 VSS 0.05744f
C277 a_15180_41600.n23 VSS 0.06817f
C278 a_15180_41600.n24 VSS 0.06817f
C279 a_15180_41600.n25 VSS 0.06817f
C280 a_15180_41600.n26 VSS 0.06817f
C281 a_15180_41600.n27 VSS 0.06817f
C282 a_15180_41600.n28 VSS 0.06817f
C283 a_15180_41600.n29 VSS 0.06817f
C284 a_15180_41600.n30 VSS 0.06817f
C285 a_15180_41600.n31 VSS 0.06817f
C286 a_15180_41600.n32 VSS 0.06817f
C287 a_15180_41600.n33 VSS 0.06817f
C288 a_15180_41600.n34 VSS 0.06817f
C289 a_15180_41600.n35 VSS 0.19841f
C290 a_15180_41600.n36 VSS 0.09807f
C291 a_15180_41600.n37 VSS 0.10512f
C292 a_15180_41600.n38 VSS 0.10512f
C293 a_15180_41600.n39 VSS 0.10512f
C294 a_15180_41600.n40 VSS 0.10512f
C295 a_15180_41600.n41 VSS 0.10512f
C296 a_15180_41600.n42 VSS 0.10512f
C297 a_15180_41600.n43 VSS 0.10512f
C298 a_15180_41600.n44 VSS 0.10512f
C299 a_15180_41600.n45 VSS 0.10512f
C300 a_15180_41600.n46 VSS 0.10512f
C301 a_15180_41600.n47 VSS 0.10512f
C302 a_15180_41600.n48 VSS 0.10512f
C303 a_15180_41600.n49 VSS 0.10512f
C304 a_15180_41600.n50 VSS 0.10512f
C305 a_15180_41600.n51 VSS 0.10512f
C306 a_15180_41600.n52 VSS 0.06817f
C307 a_15180_41600.n53 VSS 0.10512f
C308 a_15180_41600.n54 VSS 0.06817f
C309 a_15180_41600.n55 VSS 0.10512f
C310 a_15180_41600.n56 VSS 0.06817f
C311 a_15180_41600.n57 VSS 0.10512f
C312 a_15180_41600.n58 VSS 0.09807f
C313 a_15180_41600.n59 VSS 0.19841f
C314 a_15180_41600.n60 VSS 0.10512f
C315 a_15180_41600.n61 VSS 0.10512f
C316 a_15180_41600.n62 VSS 0.10512f
C317 a_15180_41600.n63 VSS 0.06817f
C318 a_15180_41600.n64 VSS 0.06817f
C319 a_15180_41600.n65 VSS 0.06817f
C320 a_15180_41600.n66 VSS 0.10512f
C321 a_15180_41600.n67 VSS 0.10512f
C322 a_15180_41600.n68 VSS 0.10512f
C323 a_15180_41600.n69 VSS 0.06817f
C324 a_15180_41600.n70 VSS 0.06817f
C325 a_15180_41600.n71 VSS 0.06817f
C326 a_15180_41600.n72 VSS 0.10512f
C327 a_15180_41600.n73 VSS 0.10512f
C328 a_15180_41600.n74 VSS 0.10512f
C329 a_15180_41600.n75 VSS 0.06817f
C330 a_15180_41600.n76 VSS 0.06817f
C331 a_15180_41600.n77 VSS 0.06817f
C332 a_15180_41600.n78 VSS 0.10512f
C333 a_15180_41600.n79 VSS 0.10512f
C334 a_15180_41600.n80 VSS 0.10512f
C335 a_15180_41600.n81 VSS 0.05744f
C336 a_15180_41600.n82 VSS 1.04087f
C337 a_15180_41600.n83 VSS 0.05744f
C338 a_15180_41600.n84 VSS 0.06817f
C339 a_15180_41600.n85 VSS 0.06817f
C340 a_15180_41600.n86 VSS 0.06817f
C341 a_15180_41600.n87 VSS 0.06817f
C342 a_15180_41600.n88 VSS 0.06817f
C343 a_15180_41600.n89 VSS 0.06817f
C344 a_15180_41600.n90 VSS 0.06817f
C345 a_15180_41600.n91 VSS 0.06817f
C346 a_15180_41600.n92 VSS 0.06817f
C347 a_15180_41600.n93 VSS 0.06817f
C348 a_15180_41600.n94 VSS 0.06817f
C349 a_15180_41600.n95 VSS 0.06817f
C350 a_15180_41600.n96 VSS 0.19841f
C351 a_15180_41600.n97 VSS 0.09807f
C352 a_15180_41600.n98 VSS 0.10512f
C353 a_15180_41600.n99 VSS 0.10512f
C354 a_15180_41600.n100 VSS 0.10512f
C355 a_15180_41600.n101 VSS 0.10512f
C356 a_15180_41600.n102 VSS 0.10512f
C357 a_15180_41600.n103 VSS 0.10512f
C358 a_15180_41600.n104 VSS 0.10512f
C359 a_15180_41600.n105 VSS 0.10512f
C360 a_15180_41600.n106 VSS 0.10512f
C361 a_15180_41600.n107 VSS 0.10512f
C362 a_15180_41600.n108 VSS 0.10512f
C363 a_15180_41600.n109 VSS 0.10512f
C364 a_15180_41600.n110 VSS 0.10512f
C365 a_15180_41600.n111 VSS 0.10512f
C366 a_15180_41600.n112 VSS 0.10512f
C367 a_15180_41600.n113 VSS 0.06817f
C368 a_15180_41600.n114 VSS 0.10512f
C369 a_15180_41600.n115 VSS 0.06817f
C370 a_15180_41600.n116 VSS 0.10512f
C371 a_15180_41600.n117 VSS 0.06817f
C372 a_15180_41600.n118 VSS 0.10512f
C373 a_15180_41600.n119 VSS 0.09807f
C374 a_15180_41600.n120 VSS 0.19841f
C375 a_15180_41600.n121 VSS 0.10512f
C376 a_15180_41600.n122 VSS 0.10512f
C377 a_15180_41600.n123 VSS 0.10512f
C378 a_15180_41600.n124 VSS 0.06817f
C379 a_15180_41600.n125 VSS 0.06817f
C380 a_15180_41600.n126 VSS 0.06817f
C381 a_15180_41600.n127 VSS 0.10512f
C382 a_15180_41600.n128 VSS 0.10512f
C383 a_15180_41600.n129 VSS 0.10512f
C384 a_15180_41600.n130 VSS 0.06817f
C385 a_15180_41600.n131 VSS 0.06817f
C386 a_15180_41600.n132 VSS 0.06817f
C387 a_15180_41600.n133 VSS 0.10512f
C388 a_15180_41600.n134 VSS 0.10512f
C389 a_15180_41600.n135 VSS 0.10512f
C390 a_15180_41600.n136 VSS 0.06817f
C391 a_15180_41600.n137 VSS 0.06817f
C392 a_15180_41600.n138 VSS 0.06817f
C393 a_15180_41600.n139 VSS 0.10512f
C394 a_15180_41600.n140 VSS 0.10512f
C395 a_15180_41600.n141 VSS 0.10512f
C396 a_15180_41600.n142 VSS 0.05744f
C397 a_15180_41600.n143 VSS 0.87815f
C398 a_15180_41600.n144 VSS 3.41399f
C399 a_15180_41600.t27 VSS 0.85793f
C400 a_15180_41600.t9 VSS 0.21197f
C401 a_15180_41600.t10 VSS 0.21197f
C402 a_15180_41600.n145 VSS 0.61673f
C403 a_15180_41600.n146 VSS 0.34758f
C404 a_15180_41600.t14 VSS 0.21197f
C405 a_15180_41600.t15 VSS 0.21197f
C406 a_15180_41600.n147 VSS 0.61673f
C407 a_15180_41600.n148 VSS 0.18286f
C408 a_15180_41600.t21 VSS 0.21197f
C409 a_15180_41600.t22 VSS 0.21197f
C410 a_15180_41600.n149 VSS 0.61673f
C411 a_15180_41600.n150 VSS 0.18286f
C412 a_15180_41600.t4 VSS 0.21197f
C413 a_15180_41600.t5 VSS 0.21197f
C414 a_15180_41600.n151 VSS 0.61673f
C415 a_15180_41600.n152 VSS 0.18286f
C416 a_15180_41600.t39 VSS 0.21197f
C417 a_15180_41600.t40 VSS 0.21197f
C418 a_15180_41600.n153 VSS 0.61673f
C419 a_15180_41600.n154 VSS 0.18286f
C420 a_15180_41600.t46 VSS 0.21197f
C421 a_15180_41600.t47 VSS 0.21197f
C422 a_15180_41600.n155 VSS 0.61673f
C423 a_15180_41600.n156 VSS 0.18286f
C424 a_15180_41600.t19 VSS 0.21197f
C425 a_15180_41600.t20 VSS 0.21197f
C426 a_15180_41600.n157 VSS 0.61673f
C427 a_15180_41600.n158 VSS 0.18286f
C428 a_15180_41600.t2 VSS 0.21197f
C429 a_15180_41600.t3 VSS 0.21197f
C430 a_15180_41600.n159 VSS 0.61673f
C431 a_15180_41600.n160 VSS 0.18286f
C432 a_15180_41600.t41 VSS 0.21197f
C433 a_15180_41600.t42 VSS 0.21197f
C434 a_15180_41600.n161 VSS 0.61673f
C435 a_15180_41600.n162 VSS 0.18286f
C436 a_15180_41600.t37 VSS 0.21197f
C437 a_15180_41600.t38 VSS 0.21197f
C438 a_15180_41600.n163 VSS 0.61673f
C439 a_15180_41600.n164 VSS 0.18286f
C440 a_15180_41600.t33 VSS 0.21197f
C441 a_15180_41600.t34 VSS 0.21197f
C442 a_15180_41600.n165 VSS 0.61673f
C443 a_15180_41600.n166 VSS 0.18286f
C444 a_15180_41600.t30 VSS 0.85234f
C445 a_15180_41600.n167 VSS 0.25011f
C446 a_15180_41600.n168 VSS 2.12893f
C447 a_15180_41600.n169 VSS 0.36885f
C448 a_15180_41600.t0 VSS 0.85383f
C449 a_2700_6400.n0 VSS 0.0539f
C450 a_2700_6400.n1 VSS 0.1862f
C451 a_2700_6400.n2 VSS 0.09204f
C452 a_2700_6400.n3 VSS 0.09865f
C453 a_2700_6400.n4 VSS 0.09865f
C454 a_2700_6400.n5 VSS 0.09865f
C455 a_2700_6400.n6 VSS 0.09204f
C456 a_2700_6400.n7 VSS 0.1862f
C457 a_2700_6400.n8 VSS 0.09865f
C458 a_2700_6400.n9 VSS 0.09865f
C459 a_2700_6400.n10 VSS 0.09865f
C460 a_2700_6400.n11 VSS 0.0539f
C461 a_2700_6400.n12 VSS 0.30259f
C462 a_2700_6400.n13 VSS 0.0539f
C463 a_2700_6400.n14 VSS 0.1862f
C464 a_2700_6400.n15 VSS 0.09204f
C465 a_2700_6400.n16 VSS 0.09865f
C466 a_2700_6400.n17 VSS 0.09865f
C467 a_2700_6400.n18 VSS 0.09865f
C468 a_2700_6400.n19 VSS 0.09204f
C469 a_2700_6400.n20 VSS 0.1862f
C470 a_2700_6400.n21 VSS 0.09865f
C471 a_2700_6400.n22 VSS 0.09865f
C472 a_2700_6400.n23 VSS 0.09865f
C473 a_2700_6400.n24 VSS 0.0539f
C474 a_2700_6400.n25 VSS 0.22663f
C475 a_2700_6400.n26 VSS 2.11369f
C476 a_2700_6400.t7 VSS 0.7899f
C477 a_2700_6400.t6 VSS 0.18399f
C478 a_2700_6400.t5 VSS 0.18399f
C479 a_2700_6400.n27 VSS 0.57877f
C480 a_2700_6400.n28 VSS 0.32618f
C481 a_2700_6400.t4 VSS 0.78466f
C482 a_2700_6400.n29 VSS 0.23471f
C483 a_2700_6400.n30 VSS 1.96684f
C484 a_2700_6400.t0 VSS 0.78606f
C485 a_2700_6400.n31 VSS 0.34615f
C486 a_2700_6400.t2 VSS 0.18399f
C487 a_2700_6400.t1 VSS 0.18399f
C488 a_2700_6400.n32 VSS 0.58307f
C489 a_2700_6400.n33 VSS 0.32049f
C490 a_2700_6400.t3 VSS 0.79129f
C491 a_4812_6400.n0 VSS 0.05635f
C492 a_4812_6400.n1 VSS 0.19467f
C493 a_4812_6400.n2 VSS 0.09622f
C494 a_4812_6400.n3 VSS 0.10314f
C495 a_4812_6400.n4 VSS 0.10314f
C496 a_4812_6400.n5 VSS 0.10314f
C497 a_4812_6400.n6 VSS 0.09622f
C498 a_4812_6400.n7 VSS 0.19467f
C499 a_4812_6400.n8 VSS 0.10314f
C500 a_4812_6400.n9 VSS 0.10314f
C501 a_4812_6400.n10 VSS 0.10314f
C502 a_4812_6400.n11 VSS 0.05635f
C503 a_4812_6400.n12 VSS 0.29267f
C504 a_4812_6400.n13 VSS 0.05635f
C505 a_4812_6400.n14 VSS 0.19467f
C506 a_4812_6400.n15 VSS 0.09622f
C507 a_4812_6400.n16 VSS 0.10314f
C508 a_4812_6400.n17 VSS 0.10314f
C509 a_4812_6400.n18 VSS 0.10314f
C510 a_4812_6400.n19 VSS 0.09622f
C511 a_4812_6400.n20 VSS 0.19467f
C512 a_4812_6400.n21 VSS 0.10314f
C513 a_4812_6400.n22 VSS 0.10314f
C514 a_4812_6400.n23 VSS 0.10314f
C515 a_4812_6400.n24 VSS 0.05635f
C516 a_4812_6400.n25 VSS 0.24991f
C517 a_4812_6400.n26 VSS 2.27959f
C518 a_4812_6400.t7 VSS 0.81015f
C519 a_4812_6400.t6 VSS 0.17696f
C520 a_4812_6400.t5 VSS 0.17696f
C521 a_4812_6400.n27 VSS 0.6051f
C522 a_4812_6400.n28 VSS 0.34102f
C523 a_4812_6400.t4 VSS 0.80467f
C524 a_4812_6400.n29 VSS 0.24539f
C525 a_4812_6400.n30 VSS 2.03081f
C526 a_4812_6400.t0 VSS 0.80613f
C527 a_4812_6400.n31 VSS 0.3619f
C528 a_4812_6400.t2 VSS 0.17696f
C529 a_4812_6400.t1 VSS 0.17696f
C530 a_4812_6400.n32 VSS 0.60959f
C531 a_4812_6400.n33 VSS 0.33507f
C532 a_4812_6400.t3 VSS 0.8116f
C533 a_6924_6400.n0 VSS 0.05175f
C534 a_6924_6400.n1 VSS 0.06142f
C535 a_6924_6400.n2 VSS 0.06142f
C536 a_6924_6400.n3 VSS 0.06142f
C537 a_6924_6400.n4 VSS 0.06142f
C538 a_6924_6400.n5 VSS 0.06142f
C539 a_6924_6400.n6 VSS 0.06142f
C540 a_6924_6400.n7 VSS 0.06142f
C541 a_6924_6400.n8 VSS 0.06142f
C542 a_6924_6400.n9 VSS 0.17878f
C543 a_6924_6400.n10 VSS 0.08837f
C544 a_6924_6400.n11 VSS 0.09472f
C545 a_6924_6400.n12 VSS 0.09472f
C546 a_6924_6400.n13 VSS 0.09472f
C547 a_6924_6400.n14 VSS 0.09472f
C548 a_6924_6400.n15 VSS 0.09472f
C549 a_6924_6400.n16 VSS 0.09472f
C550 a_6924_6400.n17 VSS 0.09472f
C551 a_6924_6400.n18 VSS 0.09472f
C552 a_6924_6400.n19 VSS 0.09472f
C553 a_6924_6400.n20 VSS 0.09472f
C554 a_6924_6400.n21 VSS 0.09472f
C555 a_6924_6400.n22 VSS 0.06142f
C556 a_6924_6400.n23 VSS 0.09472f
C557 a_6924_6400.n24 VSS 0.06142f
C558 a_6924_6400.n25 VSS 0.09472f
C559 a_6924_6400.n26 VSS 0.08837f
C560 a_6924_6400.n27 VSS 0.17878f
C561 a_6924_6400.n28 VSS 0.09472f
C562 a_6924_6400.n29 VSS 0.09472f
C563 a_6924_6400.n30 VSS 0.09472f
C564 a_6924_6400.n31 VSS 0.06142f
C565 a_6924_6400.n32 VSS 0.06142f
C566 a_6924_6400.n33 VSS 0.06142f
C567 a_6924_6400.n34 VSS 0.09472f
C568 a_6924_6400.n35 VSS 0.09472f
C569 a_6924_6400.n36 VSS 0.09472f
C570 a_6924_6400.n37 VSS 0.06142f
C571 a_6924_6400.n38 VSS 0.06142f
C572 a_6924_6400.n39 VSS 0.06142f
C573 a_6924_6400.n40 VSS 0.09472f
C574 a_6924_6400.n41 VSS 0.09472f
C575 a_6924_6400.n42 VSS 0.09472f
C576 a_6924_6400.n43 VSS 0.05175f
C577 a_6924_6400.n44 VSS 0.66009f
C578 a_6924_6400.n45 VSS 0.05175f
C579 a_6924_6400.n46 VSS 0.06142f
C580 a_6924_6400.n47 VSS 0.06142f
C581 a_6924_6400.n48 VSS 0.06142f
C582 a_6924_6400.n49 VSS 0.06142f
C583 a_6924_6400.n50 VSS 0.06142f
C584 a_6924_6400.n51 VSS 0.06142f
C585 a_6924_6400.n52 VSS 0.06142f
C586 a_6924_6400.n53 VSS 0.06142f
C587 a_6924_6400.n54 VSS 0.17878f
C588 a_6924_6400.n55 VSS 0.08837f
C589 a_6924_6400.n56 VSS 0.09472f
C590 a_6924_6400.n57 VSS 0.09472f
C591 a_6924_6400.n58 VSS 0.09472f
C592 a_6924_6400.n59 VSS 0.09472f
C593 a_6924_6400.n60 VSS 0.09472f
C594 a_6924_6400.n61 VSS 0.09472f
C595 a_6924_6400.n62 VSS 0.09472f
C596 a_6924_6400.n63 VSS 0.09472f
C597 a_6924_6400.n64 VSS 0.09472f
C598 a_6924_6400.n65 VSS 0.09472f
C599 a_6924_6400.n66 VSS 0.09472f
C600 a_6924_6400.n67 VSS 0.06142f
C601 a_6924_6400.n68 VSS 0.09472f
C602 a_6924_6400.n69 VSS 0.06142f
C603 a_6924_6400.n70 VSS 0.09472f
C604 a_6924_6400.n71 VSS 0.08837f
C605 a_6924_6400.n72 VSS 0.17878f
C606 a_6924_6400.n73 VSS 0.09472f
C607 a_6924_6400.n74 VSS 0.09472f
C608 a_6924_6400.n75 VSS 0.09472f
C609 a_6924_6400.n76 VSS 0.06142f
C610 a_6924_6400.n77 VSS 0.06142f
C611 a_6924_6400.n78 VSS 0.06142f
C612 a_6924_6400.n79 VSS 0.09472f
C613 a_6924_6400.n80 VSS 0.09472f
C614 a_6924_6400.n81 VSS 0.09472f
C615 a_6924_6400.n82 VSS 0.06142f
C616 a_6924_6400.n83 VSS 0.06142f
C617 a_6924_6400.n84 VSS 0.06142f
C618 a_6924_6400.n85 VSS 0.09472f
C619 a_6924_6400.n86 VSS 0.09472f
C620 a_6924_6400.n87 VSS 0.09472f
C621 a_6924_6400.n88 VSS 0.05175f
C622 a_6924_6400.n89 VSS 0.6519f
C623 a_6924_6400.n90 VSS 2.97932f
C624 a_6924_6400.t15 VSS 0.76131f
C625 a_6924_6400.t14 VSS 0.17949f
C626 a_6924_6400.t13 VSS 0.17949f
C627 a_6924_6400.n91 VSS 0.55569f
C628 a_6924_6400.n92 VSS 0.31318f
C629 a_6924_6400.t12 VSS 0.17949f
C630 a_6924_6400.t11 VSS 0.17949f
C631 a_6924_6400.n93 VSS 0.55569f
C632 a_6924_6400.n94 VSS 0.16476f
C633 a_6924_6400.t10 VSS 0.17949f
C634 a_6924_6400.t9 VSS 0.17949f
C635 a_6924_6400.n95 VSS 0.55569f
C636 a_6924_6400.n96 VSS 0.16476f
C637 a_6924_6400.t8 VSS 0.75628f
C638 a_6924_6400.n97 VSS 0.22535f
C639 a_6924_6400.n98 VSS 1.99322f
C640 a_6924_6400.t0 VSS 0.75762f
C641 a_6924_6400.n99 VSS 0.33235f
C642 a_6924_6400.t2 VSS 0.17949f
C643 a_6924_6400.t1 VSS 0.17949f
C644 a_6924_6400.n100 VSS 0.55982f
C645 a_6924_6400.n101 VSS 0.16064f
C646 a_6924_6400.t4 VSS 0.17949f
C647 a_6924_6400.t3 VSS 0.17949f
C648 a_6924_6400.n102 VSS 0.55982f
C649 a_6924_6400.n103 VSS 0.16064f
C650 a_6924_6400.t6 VSS 0.17949f
C651 a_6924_6400.t5 VSS 0.17949f
C652 a_6924_6400.n104 VSS 0.55982f
C653 a_6924_6400.n105 VSS 0.30772f
C654 a_6924_6400.t7 VSS 0.76264f
C655 a_15180_6400.t1 VSS 0.21197f
C656 a_15180_6400.t20 VSS 0.85941f
C657 a_15180_6400.t6 VSS 0.21197f
C658 a_15180_6400.t7 VSS 0.21197f
C659 a_15180_6400.n0 VSS 0.62131f
C660 a_15180_6400.n1 VSS 0.34152f
C661 a_15180_6400.t43 VSS 0.21197f
C662 a_15180_6400.t44 VSS 0.21197f
C663 a_15180_6400.n2 VSS 0.62131f
C664 a_15180_6400.n3 VSS 0.17828f
C665 a_15180_6400.t35 VSS 0.21197f
C666 a_15180_6400.t36 VSS 0.21197f
C667 a_15180_6400.n4 VSS 0.62131f
C668 a_15180_6400.n5 VSS 0.17828f
C669 a_15180_6400.t39 VSS 0.21197f
C670 a_15180_6400.t40 VSS 0.21197f
C671 a_15180_6400.n6 VSS 0.62131f
C672 a_15180_6400.n7 VSS 0.17828f
C673 a_15180_6400.t29 VSS 0.21197f
C674 a_15180_6400.t30 VSS 0.21197f
C675 a_15180_6400.n8 VSS 0.62131f
C676 a_15180_6400.n9 VSS 0.17828f
C677 a_15180_6400.t23 VSS 0.21197f
C678 a_15180_6400.t24 VSS 0.21197f
C679 a_15180_6400.n10 VSS 0.62131f
C680 a_15180_6400.n11 VSS 0.17828f
C681 a_15180_6400.t33 VSS 0.21197f
C682 a_15180_6400.t34 VSS 0.21197f
C683 a_15180_6400.n12 VSS 0.62131f
C684 a_15180_6400.n13 VSS 0.17828f
C685 a_15180_6400.t4 VSS 0.21197f
C686 a_15180_6400.t5 VSS 0.21197f
C687 a_15180_6400.n14 VSS 0.62131f
C688 a_15180_6400.n15 VSS 0.17828f
C689 a_15180_6400.t31 VSS 0.21197f
C690 a_15180_6400.t32 VSS 0.21197f
C691 a_15180_6400.n16 VSS 0.62131f
C692 a_15180_6400.n17 VSS 0.17828f
C693 a_15180_6400.n18 VSS 0.05744f
C694 a_15180_6400.n19 VSS 0.06817f
C695 a_15180_6400.n20 VSS 0.06817f
C696 a_15180_6400.n21 VSS 0.06817f
C697 a_15180_6400.n22 VSS 0.06817f
C698 a_15180_6400.n23 VSS 0.06817f
C699 a_15180_6400.n24 VSS 0.06817f
C700 a_15180_6400.n25 VSS 0.06817f
C701 a_15180_6400.n26 VSS 0.06817f
C702 a_15180_6400.n27 VSS 0.06817f
C703 a_15180_6400.n28 VSS 0.06817f
C704 a_15180_6400.n29 VSS 0.06817f
C705 a_15180_6400.n30 VSS 0.06817f
C706 a_15180_6400.n31 VSS 0.19841f
C707 a_15180_6400.n32 VSS 0.09807f
C708 a_15180_6400.n33 VSS 0.10512f
C709 a_15180_6400.n34 VSS 0.10512f
C710 a_15180_6400.n35 VSS 0.10512f
C711 a_15180_6400.n36 VSS 0.10512f
C712 a_15180_6400.n37 VSS 0.10512f
C713 a_15180_6400.n38 VSS 0.10512f
C714 a_15180_6400.n39 VSS 0.10512f
C715 a_15180_6400.n40 VSS 0.10512f
C716 a_15180_6400.n41 VSS 0.10512f
C717 a_15180_6400.n42 VSS 0.10512f
C718 a_15180_6400.n43 VSS 0.10512f
C719 a_15180_6400.n44 VSS 0.10512f
C720 a_15180_6400.n45 VSS 0.10512f
C721 a_15180_6400.n46 VSS 0.10512f
C722 a_15180_6400.n47 VSS 0.10512f
C723 a_15180_6400.n48 VSS 0.06817f
C724 a_15180_6400.n49 VSS 0.10512f
C725 a_15180_6400.n50 VSS 0.06817f
C726 a_15180_6400.n51 VSS 0.10512f
C727 a_15180_6400.n52 VSS 0.06817f
C728 a_15180_6400.n53 VSS 0.10512f
C729 a_15180_6400.n54 VSS 0.09807f
C730 a_15180_6400.n55 VSS 0.19841f
C731 a_15180_6400.n56 VSS 0.10512f
C732 a_15180_6400.n57 VSS 0.10512f
C733 a_15180_6400.n58 VSS 0.10512f
C734 a_15180_6400.n59 VSS 0.06817f
C735 a_15180_6400.n60 VSS 0.06817f
C736 a_15180_6400.n61 VSS 0.06817f
C737 a_15180_6400.n62 VSS 0.10512f
C738 a_15180_6400.n63 VSS 0.10512f
C739 a_15180_6400.n64 VSS 0.10512f
C740 a_15180_6400.n65 VSS 0.06817f
C741 a_15180_6400.n66 VSS 0.06817f
C742 a_15180_6400.n67 VSS 0.06817f
C743 a_15180_6400.n68 VSS 0.10512f
C744 a_15180_6400.n69 VSS 0.10512f
C745 a_15180_6400.n70 VSS 0.10512f
C746 a_15180_6400.n71 VSS 0.06817f
C747 a_15180_6400.n72 VSS 0.06817f
C748 a_15180_6400.n73 VSS 0.06817f
C749 a_15180_6400.n74 VSS 0.10512f
C750 a_15180_6400.n75 VSS 0.10512f
C751 a_15180_6400.n76 VSS 0.10512f
C752 a_15180_6400.n77 VSS 0.05744f
C753 a_15180_6400.n78 VSS 1.04087f
C754 a_15180_6400.n79 VSS 0.05744f
C755 a_15180_6400.n80 VSS 0.06817f
C756 a_15180_6400.n81 VSS 0.06817f
C757 a_15180_6400.n82 VSS 0.06817f
C758 a_15180_6400.n83 VSS 0.06817f
C759 a_15180_6400.n84 VSS 0.06817f
C760 a_15180_6400.n85 VSS 0.06817f
C761 a_15180_6400.n86 VSS 0.06817f
C762 a_15180_6400.n87 VSS 0.06817f
C763 a_15180_6400.n88 VSS 0.06817f
C764 a_15180_6400.n89 VSS 0.06817f
C765 a_15180_6400.n90 VSS 0.06817f
C766 a_15180_6400.n91 VSS 0.06817f
C767 a_15180_6400.n92 VSS 0.19841f
C768 a_15180_6400.n93 VSS 0.09807f
C769 a_15180_6400.n94 VSS 0.10512f
C770 a_15180_6400.n95 VSS 0.10512f
C771 a_15180_6400.n96 VSS 0.10512f
C772 a_15180_6400.n97 VSS 0.10512f
C773 a_15180_6400.n98 VSS 0.10512f
C774 a_15180_6400.n99 VSS 0.10512f
C775 a_15180_6400.n100 VSS 0.10512f
C776 a_15180_6400.n101 VSS 0.10512f
C777 a_15180_6400.n102 VSS 0.10512f
C778 a_15180_6400.n103 VSS 0.10512f
C779 a_15180_6400.n104 VSS 0.10512f
C780 a_15180_6400.n105 VSS 0.10512f
C781 a_15180_6400.n106 VSS 0.10512f
C782 a_15180_6400.n107 VSS 0.10512f
C783 a_15180_6400.n108 VSS 0.10512f
C784 a_15180_6400.n109 VSS 0.06817f
C785 a_15180_6400.n110 VSS 0.10512f
C786 a_15180_6400.n111 VSS 0.06817f
C787 a_15180_6400.n112 VSS 0.10512f
C788 a_15180_6400.n113 VSS 0.06817f
C789 a_15180_6400.n114 VSS 0.10512f
C790 a_15180_6400.n115 VSS 0.09807f
C791 a_15180_6400.n116 VSS 0.19841f
C792 a_15180_6400.n117 VSS 0.10512f
C793 a_15180_6400.n118 VSS 0.10512f
C794 a_15180_6400.n119 VSS 0.10512f
C795 a_15180_6400.n120 VSS 0.06817f
C796 a_15180_6400.n121 VSS 0.06817f
C797 a_15180_6400.n122 VSS 0.06817f
C798 a_15180_6400.n123 VSS 0.10512f
C799 a_15180_6400.n124 VSS 0.10512f
C800 a_15180_6400.n125 VSS 0.10512f
C801 a_15180_6400.n126 VSS 0.06817f
C802 a_15180_6400.n127 VSS 0.06817f
C803 a_15180_6400.n128 VSS 0.06817f
C804 a_15180_6400.n129 VSS 0.10512f
C805 a_15180_6400.n130 VSS 0.10512f
C806 a_15180_6400.n131 VSS 0.10512f
C807 a_15180_6400.n132 VSS 0.06817f
C808 a_15180_6400.n133 VSS 0.06817f
C809 a_15180_6400.n134 VSS 0.06817f
C810 a_15180_6400.n135 VSS 0.10512f
C811 a_15180_6400.n136 VSS 0.10512f
C812 a_15180_6400.n137 VSS 0.10512f
C813 a_15180_6400.n138 VSS 0.05744f
C814 a_15180_6400.n139 VSS 0.87815f
C815 a_15180_6400.n140 VSS 3.41399f
C816 a_15180_6400.t12 VSS 0.85793f
C817 a_15180_6400.t27 VSS 0.21197f
C818 a_15180_6400.t28 VSS 0.21197f
C819 a_15180_6400.n141 VSS 0.61673f
C820 a_15180_6400.n142 VSS 0.34758f
C821 a_15180_6400.t37 VSS 0.21197f
C822 a_15180_6400.t38 VSS 0.21197f
C823 a_15180_6400.n143 VSS 0.61673f
C824 a_15180_6400.n144 VSS 0.18286f
C825 a_15180_6400.t21 VSS 0.21197f
C826 a_15180_6400.t22 VSS 0.21197f
C827 a_15180_6400.n145 VSS 0.61673f
C828 a_15180_6400.n146 VSS 0.18286f
C829 a_15180_6400.t46 VSS 0.21197f
C830 a_15180_6400.t47 VSS 0.21197f
C831 a_15180_6400.n147 VSS 0.61673f
C832 a_15180_6400.n148 VSS 0.18286f
C833 a_15180_6400.t41 VSS 0.21197f
C834 a_15180_6400.t42 VSS 0.21197f
C835 a_15180_6400.n149 VSS 0.61673f
C836 a_15180_6400.n150 VSS 0.18286f
C837 a_15180_6400.t13 VSS 0.21197f
C838 a_15180_6400.t14 VSS 0.21197f
C839 a_15180_6400.n151 VSS 0.61673f
C840 a_15180_6400.n152 VSS 0.18286f
C841 a_15180_6400.t8 VSS 0.21197f
C842 a_15180_6400.t9 VSS 0.21197f
C843 a_15180_6400.n153 VSS 0.61673f
C844 a_15180_6400.n154 VSS 0.18286f
C845 a_15180_6400.t2 VSS 0.21197f
C846 a_15180_6400.t3 VSS 0.21197f
C847 a_15180_6400.n155 VSS 0.61673f
C848 a_15180_6400.n156 VSS 0.18286f
C849 a_15180_6400.t17 VSS 0.21197f
C850 a_15180_6400.t18 VSS 0.21197f
C851 a_15180_6400.n157 VSS 0.61673f
C852 a_15180_6400.n158 VSS 0.18286f
C853 a_15180_6400.t10 VSS 0.21197f
C854 a_15180_6400.t11 VSS 0.21197f
C855 a_15180_6400.n159 VSS 0.61673f
C856 a_15180_6400.n160 VSS 0.18286f
C857 a_15180_6400.t15 VSS 0.21197f
C858 a_15180_6400.t16 VSS 0.21197f
C859 a_15180_6400.n161 VSS 0.61673f
C860 a_15180_6400.n162 VSS 0.18286f
C861 a_15180_6400.t19 VSS 0.85234f
C862 a_15180_6400.n163 VSS 0.25011f
C863 a_15180_6400.n164 VSS 2.12893f
C864 a_15180_6400.t45 VSS 0.85383f
C865 a_15180_6400.n165 VSS 0.36885f
C866 a_15180_6400.t25 VSS 0.21197f
C867 a_15180_6400.t26 VSS 0.21197f
C868 a_15180_6400.n166 VSS 0.62131f
C869 a_15180_6400.n167 VSS 0.17828f
C870 a_15180_6400.n168 VSS 0.17828f
C871 a_15180_6400.n169 VSS 0.62131f
C872 a_15180_6400.t0 VSS 0.21197f
C873 VSS.t39 VSS 0.10203f
C874 VSS.t103 VSS 0.10399f
C875 VSS.t191 VSS 0.10203f
C876 VSS.t37 VSS 0.10203f
C877 VSS.t211 VSS 0.10203f
C878 VSS.t189 VSS 0.10203f
C879 VSS.t107 VSS 0.10203f
C880 VSS.t209 VSS 0.10203f
C881 VSS.t43 VSS 0.10203f
C882 VSS.t105 VSS 0.10203f
C883 VSS.t195 VSS 0.10203f
C884 VSS.t41 VSS 0.10203f
C885 VSS.t215 VSS 0.10203f
C886 VSS.t193 VSS 0.10203f
C887 VSS.t113 VSS 0.10203f
C888 VSS.t213 VSS 0.10203f
C889 VSS.t49 VSS 0.10203f
C890 VSS.t111 VSS 0.10203f
C891 VSS.t199 VSS 0.10203f
C892 VSS.t47 VSS 0.10203f
C893 VSS.t219 VSS 0.10203f
C894 VSS.t197 VSS 0.10203f
C895 VSS.t117 VSS 0.10203f
C896 VSS.t217 VSS 0.10203f
C897 VSS.t53 VSS 0.10203f
C898 VSS.t115 VSS 0.10203f
C899 VSS.t203 VSS 0.10203f
C900 VSS.t51 VSS 0.10203f
C901 VSS.t57 VSS 0.10203f
C902 VSS.t201 VSS 0.10203f
C903 VSS.t159 VSS 0.10399f
C904 VSS.t55 VSS 0.10203f
C905 VSS.t175 VSS 0.09193f
C906 VSS.t183 VSS 0.0937f
C907 VSS.t95 VSS 0.09193f
C908 VSS.t173 VSS 0.09193f
C909 VSS.t179 VSS 0.09193f
C910 VSS.t93 VSS 0.09193f
C911 VSS.t15 VSS 0.09193f
C912 VSS.t177 VSS 0.09193f
C913 VSS.t79 VSS 0.09193f
C914 VSS.t13 VSS 0.09193f
C915 VSS.t171 VSS 0.09193f
C916 VSS.t77 VSS 0.09193f
C917 VSS.t293 VSS 0.09193f
C918 VSS.t169 VSS 0.09193f
C919 VSS.t335 VSS 0.09193f
C920 VSS.t291 VSS 0.09193f
C921 VSS.t187 VSS 0.09193f
C922 VSS.t333 VSS 0.09193f
C923 VSS.t283 VSS 0.09193f
C924 VSS.t185 VSS 0.09193f
C925 VSS.t257 VSS 0.09193f
C926 VSS.t281 VSS 0.09193f
C927 VSS.t157 VSS 0.0937f
C928 VSS.t255 VSS 0.09193f
C929 VSS.t351 VSS 0.10011f
C930 VSS.t67 VSS 0.10203f
C931 VSS.t27 VSS 0.10011f
C932 VSS.t181 VSS 0.10011f
C933 VSS.t289 VSS 0.10011f
C934 VSS.t231 VSS 0.10011f
C935 VSS.t25 VSS 0.10203f
C936 VSS.t325 VSS 0.10011f
C937 VSS.t341 VSS 0.09575f
C938 VSS.t239 VSS 0.09759f
C939 VSS.t45 VSS 0.09575f
C940 VSS.t349 VSS 0.09575f
C941 VSS.t223 VSS 0.09575f
C942 VSS.t109 VSS 0.09575f
C943 VSS.t123 VSS 0.09759f
C944 VSS.t85 VSS 0.09575f
C945 VSS.t307 VSS 0.07134f
C946 VSS.t305 VSS 0.07271f
C947 VSS.t297 VSS 0.07134f
C948 VSS.t309 VSS 0.07134f
C949 VSS.t313 VSS 0.07134f
C950 VSS.t311 VSS 0.07134f
C951 VSS.t317 VSS 0.07271f
C952 VSS.t315 VSS 0.07134f
C953 VSS.t71 VSS 0.0592f
C954 VSS.t69 VSS 0.06033f
C955 VSS.t75 VSS 0.06033f
C956 VSS.t73 VSS 0.0592f
C957 VSS.t299 VSS 0.07134f
C958 VSS.t295 VSS 0.07271f
C959 VSS.t303 VSS 0.07271f
C960 VSS.t301 VSS 0.07134f
C961 VSS.t345 VSS 0.10203f
C962 VSS.t225 VSS 0.10399f
C963 VSS.t319 VSS 0.10203f
C964 VSS.t259 VSS 0.10203f
C965 VSS.t161 VSS 0.10203f
C966 VSS.t59 VSS 0.10203f
C967 VSS.t347 VSS 0.10203f
C968 VSS.t205 VSS 0.10203f
C969 VSS.t207 VSS 0.10203f
C970 VSS.t327 VSS 0.10203f
C971 VSS.t275 VSS 0.10203f
C972 VSS.t279 VSS 0.10203f
C973 VSS.t163 VSS 0.10203f
C974 VSS.t61 VSS 0.10203f
C975 VSS.t1 VSS 0.10203f
C976 VSS.t89 VSS 0.10203f
C977 VSS.t165 VSS 0.10203f
C978 VSS.t63 VSS 0.10203f
C979 VSS.t91 VSS 0.10203f
C980 VSS.t277 VSS 0.10203f
C981 VSS.t65 VSS 0.10203f
C982 VSS.t3 VSS 0.10203f
C983 VSS.t227 VSS 0.10203f
C984 VSS.t167 VSS 0.10203f
C985 VSS.t329 VSS 0.10203f
C986 VSS.t233 VSS 0.10203f
C987 VSS.t245 VSS 0.10203f
C988 VSS.t235 VSS 0.10203f
C989 VSS.t343 VSS 0.10203f
C990 VSS.t221 VSS 0.10203f
C991 VSS.t331 VSS 0.10399f
C992 VSS.t261 VSS 0.10203f
C993 VSS.t249 VSS 0.09193f
C994 VSS.t237 VSS 0.0937f
C995 VSS.t265 VSS 0.09193f
C996 VSS.t247 VSS 0.09193f
C997 VSS.t323 VSS 0.09193f
C998 VSS.t263 VSS 0.09193f
C999 VSS.t19 VSS 0.09193f
C1000 VSS.t321 VSS 0.09193f
C1001 VSS.t151 VSS 0.09193f
C1002 VSS.t17 VSS 0.09193f
C1003 VSS.t339 VSS 0.09193f
C1004 VSS.t149 VSS 0.09193f
C1005 VSS.t287 VSS 0.09193f
C1006 VSS.t337 VSS 0.09193f
C1007 VSS.t23 VSS 0.09193f
C1008 VSS.t285 VSS 0.09193f
C1009 VSS.t155 VSS 0.09193f
C1010 VSS.t21 VSS 0.09193f
C1011 VSS.t121 VSS 0.09193f
C1012 VSS.t153 VSS 0.09193f
C1013 VSS.t83 VSS 0.09193f
C1014 VSS.t119 VSS 0.09193f
C1015 VSS.t229 VSS 0.0937f
C1016 VSS.t81 VSS 0.09193f
C1017 VSS.t241 VSS 0.10011f
C1018 VSS.t243 VSS 0.10203f
C1019 VSS.t251 VSS 0.10011f
C1020 VSS.t253 VSS 0.10011f
C1021 VSS.t267 VSS 0.10011f
C1022 VSS.t269 VSS 0.10011f
C1023 VSS.t271 VSS 0.10203f
C1024 VSS.t273 VSS 0.10011f
C1025 VSS.t29 VSS 0.09575f
C1026 VSS.t31 VSS 0.09759f
C1027 VSS.t97 VSS 0.09575f
C1028 VSS.t99 VSS 0.09575f
C1029 VSS.t33 VSS 0.09575f
C1030 VSS.t35 VSS 0.09575f
C1031 VSS.t87 VSS 0.09759f
C1032 VSS.t101 VSS 0.09575f
C1033 VSS.t137 VSS 0.0703f
C1034 VSS.t125 VSS 0.07165f
C1035 VSS.t127 VSS 0.0703f
C1036 VSS.t139 VSS 0.0703f
C1037 VSS.t143 VSS 0.0703f
C1038 VSS.t141 VSS 0.0703f
C1039 VSS.t147 VSS 0.07165f
C1040 VSS.t145 VSS 0.0703f
C1041 VSS.t7 VSS 0.0592f
C1042 VSS.t5 VSS 0.06033f
C1043 VSS.t11 VSS 0.06033f
C1044 VSS.t9 VSS 0.0592f
C1045 VSS.t129 VSS 0.0703f
C1046 VSS.t131 VSS 0.07165f
C1047 VSS.t135 VSS 0.07165f
C1048 VSS.t133 VSS 0.0703f
C1049 VDD.t94 VSS 2.83467f
C1050 VDD.t188 VSS 0.1376f
C1051 VDD.t190 VSS 0.1376f
C1052 VDD.t164 VSS 0.1376f
C1053 VDD.t166 VSS 0.1376f
C1054 VDD.t34 VSS 0.1376f
C1055 VDD.t36 VSS 0.1376f
C1056 VDD.t90 VSS 0.1376f
C1057 VDD.t92 VSS 0.1376f
C1058 VDD.t184 VSS 0.1376f
C1059 VDD.t186 VSS 0.1376f
C1060 VDD.t268 VSS 0.1376f
C1061 VDD.t270 VSS 0.1376f
C1062 VDD.t160 VSS 0.1376f
C1063 VDD.t162 VSS 0.1376f
C1064 VDD.t30 VSS 0.1376f
C1065 VDD.t32 VSS 0.1376f
C1066 VDD.t86 VSS 0.1376f
C1067 VDD.t88 VSS 0.1376f
C1068 VDD.t180 VSS 0.1376f
C1069 VDD.t182 VSS 0.1376f
C1070 VDD.t264 VSS 0.1376f
C1071 VDD.t266 VSS 0.1376f
C1072 VDD.t156 VSS 0.1376f
C1073 VDD.t158 VSS 0.1376f
C1074 VDD.t26 VSS 0.1376f
C1075 VDD.t28 VSS 0.1376f
C1076 VDD.t82 VSS 0.1376f
C1077 VDD.t84 VSS 0.1376f
C1078 VDD.t176 VSS 0.1376f
C1079 VDD.t178 VSS 0.1376f
C1080 VDD.t154 VSS 0.77059f
C1081 VDD.t144 VSS 0.77059f
C1082 VDD.t50 VSS 0.1376f
C1083 VDD.t52 VSS 0.1376f
C1084 VDD.t292 VSS 0.1376f
C1085 VDD.t294 VSS 0.1376f
C1086 VDD.t284 VSS 0.1376f
C1087 VDD.t286 VSS 0.1376f
C1088 VDD.t288 VSS 0.1376f
C1089 VDD.t290 VSS 0.1376f
C1090 VDD.t254 VSS 0.1376f
C1091 VDD.t256 VSS 0.1376f
C1092 VDD.t146 VSS 0.1376f
C1093 VDD.t148 VSS 0.1376f
C1094 VDD.t280 VSS 0.1376f
C1095 VDD.t282 VSS 0.1376f
C1096 VDD.t46 VSS 0.1376f
C1097 VDD.t48 VSS 0.1376f
C1098 VDD.t276 VSS 0.1376f
C1099 VDD.t278 VSS 0.1376f
C1100 VDD.t6 VSS 0.1376f
C1101 VDD.t8 VSS 0.1376f
C1102 VDD.t150 VSS 0.1376f
C1103 VDD.t152 VSS 0.1376f
C1104 VDD.t320 VSS 0.77059f
C1105 VDD.t172 VSS 0.77059f
C1106 VDD.t340 VSS 0.1376f
C1107 VDD.t96 VSS 0.1376f
C1108 VDD.t174 VSS 0.1376f
C1109 VDD.t328 VSS 0.1376f
C1110 VDD.t250 VSS 0.1376f
C1111 VDD.t274 VSS 0.1376f
C1112 VDD.t142 VSS 0.77059f
C1113 VDD.t350 VSS 0.77059f
C1114 VDD.t232 VSS 0.1376f
C1115 VDD.t346 VSS 0.1376f
C1116 VDD.t258 VSS 0.1376f
C1117 VDD.t262 VSS 0.1376f
C1118 VDD.t260 VSS 0.1376f
C1119 VDD.t230 VSS 0.1376f
C1120 VDD.t348 VSS 0.77059f
C1121 VDD.t318 VSS 0.77059f
C1122 VDD.t316 VSS 0.1376f
C1123 VDD.t314 VSS 0.1376f
C1124 VDD.t296 VSS 0.1376f
C1125 VDD.t306 VSS 0.1376f
C1126 VDD.t312 VSS 0.1376f
C1127 VDD.t310 VSS 0.1376f
C1128 VDD.t308 VSS 0.77059f
C1129 VDD.t60 VSS 0.77059f
C1130 VDD.t58 VSS 0.1376f
C1131 VDD.t56 VSS 0.1376f
C1132 VDD.t54 VSS 0.77059f
C1133 VDD.t304 VSS 0.77059f
C1134 VDD.t302 VSS 0.1376f
C1135 VDD.t300 VSS 0.1376f
C1136 VDD.t298 VSS 0.77127f
C1137 VDD.t179 VSS 0.11192f
C1138 VDD.t155 VSS 0.11387f
C1139 VDD.n1 VSS 0.05156f
C1140 VDD.t85 VSS 0.11192f
C1141 VDD.t177 VSS 0.11192f
C1142 VDD.n2 VSS 0.05116f
C1143 VDD.n3 VSS 0.02592f
C1144 VDD.t29 VSS 0.11192f
C1145 VDD.t83 VSS 0.11192f
C1146 VDD.n4 VSS 0.05116f
C1147 VDD.n5 VSS 0.01468f
C1148 VDD.t159 VSS 0.11192f
C1149 VDD.t27 VSS 0.11192f
C1150 VDD.n6 VSS 0.05116f
C1151 VDD.n7 VSS 0.01468f
C1152 VDD.t267 VSS 0.11192f
C1153 VDD.t157 VSS 0.11192f
C1154 VDD.n8 VSS 0.05116f
C1155 VDD.n9 VSS 0.01468f
C1156 VDD.t183 VSS 0.11192f
C1157 VDD.t265 VSS 0.11192f
C1158 VDD.n10 VSS 0.05116f
C1159 VDD.n11 VSS 0.01468f
C1160 VDD.t89 VSS 0.11192f
C1161 VDD.t181 VSS 0.11192f
C1162 VDD.n12 VSS 0.05116f
C1163 VDD.n13 VSS 0.01468f
C1164 VDD.t33 VSS 0.11192f
C1165 VDD.t87 VSS 0.11192f
C1166 VDD.n14 VSS 0.05116f
C1167 VDD.n15 VSS 0.01468f
C1168 VDD.t163 VSS 0.11192f
C1169 VDD.t31 VSS 0.11192f
C1170 VDD.n16 VSS 0.05116f
C1171 VDD.n17 VSS 0.01468f
C1172 VDD.t271 VSS 0.11192f
C1173 VDD.t161 VSS 0.11192f
C1174 VDD.n18 VSS 0.05116f
C1175 VDD.n19 VSS 0.01468f
C1176 VDD.t187 VSS 0.11192f
C1177 VDD.t269 VSS 0.11192f
C1178 VDD.n20 VSS 0.05116f
C1179 VDD.n21 VSS 0.01468f
C1180 VDD.t93 VSS 0.11192f
C1181 VDD.t185 VSS 0.11192f
C1182 VDD.n22 VSS 0.05116f
C1183 VDD.n23 VSS 0.01468f
C1184 VDD.t37 VSS 0.11192f
C1185 VDD.t91 VSS 0.11192f
C1186 VDD.n24 VSS 0.05116f
C1187 VDD.n25 VSS 0.01468f
C1188 VDD.t167 VSS 0.11192f
C1189 VDD.t35 VSS 0.11192f
C1190 VDD.n26 VSS 0.05116f
C1191 VDD.n27 VSS 0.01468f
C1192 VDD.t191 VSS 0.11192f
C1193 VDD.t165 VSS 0.11192f
C1194 VDD.n28 VSS 0.05116f
C1195 VDD.n29 VSS 0.01468f
C1196 VDD.t95 VSS 0.11387f
C1197 VDD.t189 VSS 0.11192f
C1198 VDD.n30 VSS 0.05116f
C1199 VDD.n31 VSS 0.09939f
C1200 VDD.t153 VSS 0.10182f
C1201 VDD.t321 VSS 0.10358f
C1202 VDD.n32 VSS 0.05156f
C1203 VDD.t9 VSS 0.10182f
C1204 VDD.t151 VSS 0.10182f
C1205 VDD.n33 VSS 0.05116f
C1206 VDD.n34 VSS 0.02592f
C1207 VDD.t279 VSS 0.10182f
C1208 VDD.t7 VSS 0.10182f
C1209 VDD.n35 VSS 0.05116f
C1210 VDD.n36 VSS 0.01468f
C1211 VDD.t49 VSS 0.10182f
C1212 VDD.t277 VSS 0.10182f
C1213 VDD.n37 VSS 0.05116f
C1214 VDD.n38 VSS 0.01468f
C1215 VDD.t283 VSS 0.10182f
C1216 VDD.t47 VSS 0.10182f
C1217 VDD.n39 VSS 0.05116f
C1218 VDD.n40 VSS 0.01468f
C1219 VDD.t149 VSS 0.10182f
C1220 VDD.t281 VSS 0.10182f
C1221 VDD.n41 VSS 0.05116f
C1222 VDD.n42 VSS 0.01468f
C1223 VDD.t257 VSS 0.10182f
C1224 VDD.t147 VSS 0.10182f
C1225 VDD.n43 VSS 0.05116f
C1226 VDD.n44 VSS 0.01468f
C1227 VDD.t291 VSS 0.10182f
C1228 VDD.t255 VSS 0.10182f
C1229 VDD.n45 VSS 0.05116f
C1230 VDD.n46 VSS 0.01468f
C1231 VDD.t287 VSS 0.10182f
C1232 VDD.t289 VSS 0.10182f
C1233 VDD.n47 VSS 0.05116f
C1234 VDD.n48 VSS 0.01468f
C1235 VDD.t295 VSS 0.10182f
C1236 VDD.t285 VSS 0.10182f
C1237 VDD.n49 VSS 0.05116f
C1238 VDD.n50 VSS 0.01468f
C1239 VDD.t53 VSS 0.10182f
C1240 VDD.t293 VSS 0.10182f
C1241 VDD.n51 VSS 0.05116f
C1242 VDD.n52 VSS 0.01468f
C1243 VDD.t145 VSS 0.10358f
C1244 VDD.t51 VSS 0.10182f
C1245 VDD.n53 VSS 0.05116f
C1246 VDD.n54 VSS 0.05731f
C1247 VDD.n55 VSS 1.79955f
C1248 VDD.t275 VSS 0.10999f
C1249 VDD.t143 VSS 0.11191f
C1250 VDD.n56 VSS 0.05156f
C1251 VDD.t329 VSS 0.10999f
C1252 VDD.t251 VSS 0.10999f
C1253 VDD.n57 VSS 0.05116f
C1254 VDD.n58 VSS 0.02592f
C1255 VDD.t97 VSS 0.10999f
C1256 VDD.t175 VSS 0.10999f
C1257 VDD.n59 VSS 0.05116f
C1258 VDD.n60 VSS 0.01468f
C1259 VDD.t173 VSS 0.11191f
C1260 VDD.t341 VSS 0.10999f
C1261 VDD.n61 VSS 0.05116f
C1262 VDD.n62 VSS 0.05731f
C1263 VDD.n63 VSS 0.80107f
C1264 VDD.t231 VSS 0.10564f
C1265 VDD.t349 VSS 0.10747f
C1266 VDD.n64 VSS 0.05156f
C1267 VDD.t263 VSS 0.10564f
C1268 VDD.t261 VSS 0.10564f
C1269 VDD.n65 VSS 0.05116f
C1270 VDD.n66 VSS 0.02592f
C1271 VDD.t347 VSS 0.10564f
C1272 VDD.t259 VSS 0.10564f
C1273 VDD.n67 VSS 0.05116f
C1274 VDD.n68 VSS 0.01468f
C1275 VDD.t351 VSS 0.10747f
C1276 VDD.t233 VSS 0.10564f
C1277 VDD.n69 VSS 0.05116f
C1278 VDD.n70 VSS 0.05731f
C1279 VDD.n71 VSS 0.55779f
C1280 VDD.t311 VSS 0.08123f
C1281 VDD.t309 VSS 0.08259f
C1282 VDD.n72 VSS 0.05156f
C1283 VDD.t307 VSS 0.08123f
C1284 VDD.t313 VSS 0.08123f
C1285 VDD.n73 VSS 0.05116f
C1286 VDD.n74 VSS 0.02592f
C1287 VDD.t315 VSS 0.08123f
C1288 VDD.t297 VSS 0.08123f
C1289 VDD.n75 VSS 0.05116f
C1290 VDD.n76 VSS 0.01468f
C1291 VDD.t319 VSS 0.08259f
C1292 VDD.t317 VSS 0.08123f
C1293 VDD.n77 VSS 0.05116f
C1294 VDD.n78 VSS 0.05731f
C1295 VDD.n79 VSS 0.55779f
C1296 VDD.t57 VSS 0.06908f
C1297 VDD.t55 VSS 0.07022f
C1298 VDD.n80 VSS 0.05156f
C1299 VDD.t61 VSS 0.07022f
C1300 VDD.t59 VSS 0.06908f
C1301 VDD.n81 VSS 0.05116f
C1302 VDD.n82 VSS 0.06855f
C1303 VDD.n83 VSS 0.49697f
C1304 VDD.t301 VSS 0.08123f
C1305 VDD.t299 VSS 0.08259f
C1306 VDD.n84 VSS 0.05156f
C1307 VDD.t305 VSS 0.08259f
C1308 VDD.t303 VSS 0.08123f
C1309 VDD.n85 VSS 0.05116f
C1310 VDD.n86 VSS 0.06855f
C1311 VDD.n87 VSS 0.56143f
C1312 VDD.n88 VSS 44.7721f
C1313 VDD.n89 VSS 74.7695f
C1314 VDD.t170 VSS 2.83467f
C1315 VDD.t140 VSS 0.1376f
C1316 VDD.t44 VSS 0.1376f
C1317 VDD.t226 VSS 0.1376f
C1318 VDD.t4 VSS 0.1376f
C1319 VDD.t72 VSS 0.1376f
C1320 VDD.t214 VSS 0.1376f
C1321 VDD.t326 VSS 0.1376f
C1322 VDD.t238 VSS 0.1376f
C1323 VDD.t344 VSS 0.1376f
C1324 VDD.t192 VSS 0.1376f
C1325 VDD.t168 VSS 0.1376f
C1326 VDD.t224 VSS 0.1376f
C1327 VDD.t212 VSS 0.1376f
C1328 VDD.t324 VSS 0.1376f
C1329 VDD.t208 VSS 0.1376f
C1330 VDD.t206 VSS 0.1376f
C1331 VDD.t138 VSS 0.1376f
C1332 VDD.t42 VSS 0.1376f
C1333 VDD.t2 VSS 0.1376f
C1334 VDD.t70 VSS 0.1376f
C1335 VDD.t248 VSS 0.1376f
C1336 VDD.t136 VSS 0.1376f
C1337 VDD.t40 VSS 0.1376f
C1338 VDD.t0 VSS 0.1376f
C1339 VDD.t68 VSS 0.1376f
C1340 VDD.t134 VSS 0.1376f
C1341 VDD.t38 VSS 0.1376f
C1342 VDD.t252 VSS 0.1376f
C1343 VDD.t272 VSS 0.1376f
C1344 VDD.t322 VSS 0.1376f
C1345 VDD.t342 VSS 0.77059f
C1346 VDD.t218 VSS 0.77059f
C1347 VDD.t332 VSS 0.1376f
C1348 VDD.t334 VSS 0.1376f
C1349 VDD.t198 VSS 0.1376f
C1350 VDD.t200 VSS 0.1376f
C1351 VDD.t240 VSS 0.1376f
C1352 VDD.t242 VSS 0.1376f
C1353 VDD.t194 VSS 0.1376f
C1354 VDD.t196 VSS 0.1376f
C1355 VDD.t64 VSS 0.1376f
C1356 VDD.t66 VSS 0.1376f
C1357 VDD.t100 VSS 0.1376f
C1358 VDD.t102 VSS 0.1376f
C1359 VDD.t130 VSS 0.1376f
C1360 VDD.t132 VSS 0.1376f
C1361 VDD.t228 VSS 0.1376f
C1362 VDD.t20 VSS 0.1376f
C1363 VDD.t216 VSS 0.1376f
C1364 VDD.t330 VSS 0.1376f
C1365 VDD.t210 VSS 0.1376f
C1366 VDD.t62 VSS 0.1376f
C1367 VDD.t98 VSS 0.1376f
C1368 VDD.t128 VSS 0.1376f
C1369 VDD.t18 VSS 0.77059f
C1370 VDD.t336 VSS 0.77059f
C1371 VDD.t338 VSS 0.1376f
C1372 VDD.t244 VSS 0.1376f
C1373 VDD.t246 VSS 0.1376f
C1374 VDD.t234 VSS 0.1376f
C1375 VDD.t236 VSS 0.1376f
C1376 VDD.t220 VSS 0.1376f
C1377 VDD.t222 VSS 0.77059f
C1378 VDD.t78 VSS 0.77059f
C1379 VDD.t80 VSS 0.1376f
C1380 VDD.t202 VSS 0.1376f
C1381 VDD.t204 VSS 0.1376f
C1382 VDD.t22 VSS 0.1376f
C1383 VDD.t24 VSS 0.1376f
C1384 VDD.t74 VSS 0.1376f
C1385 VDD.t76 VSS 0.77059f
C1386 VDD.t126 VSS 0.77059f
C1387 VDD.t124 VSS 0.1376f
C1388 VDD.t122 VSS 0.1376f
C1389 VDD.t110 VSS 0.1376f
C1390 VDD.t120 VSS 0.1376f
C1391 VDD.t118 VSS 0.1376f
C1392 VDD.t116 VSS 0.1376f
C1393 VDD.t114 VSS 0.77059f
C1394 VDD.t16 VSS 0.77059f
C1395 VDD.t14 VSS 0.1376f
C1396 VDD.t12 VSS 0.1376f
C1397 VDD.t10 VSS 0.77059f
C1398 VDD.t112 VSS 0.77059f
C1399 VDD.t108 VSS 0.1376f
C1400 VDD.t106 VSS 0.1376f
C1401 VDD.t104 VSS 0.77127f
C1402 VDD.t323 VSS 0.11192f
C1403 VDD.t343 VSS 0.11387f
C1404 VDD.n90 VSS 0.05156f
C1405 VDD.t253 VSS 0.11192f
C1406 VDD.t273 VSS 0.11192f
C1407 VDD.n91 VSS 0.05116f
C1408 VDD.n92 VSS 0.02592f
C1409 VDD.t135 VSS 0.11192f
C1410 VDD.t39 VSS 0.11192f
C1411 VDD.n93 VSS 0.05116f
C1412 VDD.n94 VSS 0.01468f
C1413 VDD.t1 VSS 0.11192f
C1414 VDD.t69 VSS 0.11192f
C1415 VDD.n95 VSS 0.05116f
C1416 VDD.n96 VSS 0.01468f
C1417 VDD.t137 VSS 0.11192f
C1418 VDD.t41 VSS 0.11192f
C1419 VDD.n97 VSS 0.05116f
C1420 VDD.n98 VSS 0.01468f
C1421 VDD.t71 VSS 0.11192f
C1422 VDD.t249 VSS 0.11192f
C1423 VDD.n99 VSS 0.05116f
C1424 VDD.n100 VSS 0.01468f
C1425 VDD.t43 VSS 0.11192f
C1426 VDD.t3 VSS 0.11192f
C1427 VDD.n101 VSS 0.05116f
C1428 VDD.n102 VSS 0.01468f
C1429 VDD.t207 VSS 0.11192f
C1430 VDD.t139 VSS 0.11192f
C1431 VDD.n103 VSS 0.05116f
C1432 VDD.n104 VSS 0.01468f
C1433 VDD.t325 VSS 0.11192f
C1434 VDD.t209 VSS 0.11192f
C1435 VDD.n105 VSS 0.05116f
C1436 VDD.n106 VSS 0.01468f
C1437 VDD.t225 VSS 0.11192f
C1438 VDD.t213 VSS 0.11192f
C1439 VDD.n107 VSS 0.05116f
C1440 VDD.n108 VSS 0.01468f
C1441 VDD.t193 VSS 0.11192f
C1442 VDD.t169 VSS 0.11192f
C1443 VDD.n109 VSS 0.05116f
C1444 VDD.n110 VSS 0.01468f
C1445 VDD.t239 VSS 0.11192f
C1446 VDD.t345 VSS 0.11192f
C1447 VDD.n111 VSS 0.05116f
C1448 VDD.n112 VSS 0.01468f
C1449 VDD.t215 VSS 0.11192f
C1450 VDD.t327 VSS 0.11192f
C1451 VDD.n113 VSS 0.05116f
C1452 VDD.n114 VSS 0.01468f
C1453 VDD.t5 VSS 0.11192f
C1454 VDD.t73 VSS 0.11192f
C1455 VDD.n115 VSS 0.05116f
C1456 VDD.n116 VSS 0.01468f
C1457 VDD.t45 VSS 0.11192f
C1458 VDD.t227 VSS 0.11192f
C1459 VDD.n117 VSS 0.05116f
C1460 VDD.n118 VSS 0.01468f
C1461 VDD.t171 VSS 0.11387f
C1462 VDD.t141 VSS 0.11192f
C1463 VDD.n119 VSS 0.05116f
C1464 VDD.n120 VSS 0.09939f
C1465 VDD.t129 VSS 0.10182f
C1466 VDD.t19 VSS 0.10358f
C1467 VDD.n121 VSS 0.05156f
C1468 VDD.t63 VSS 0.10182f
C1469 VDD.t99 VSS 0.10182f
C1470 VDD.n122 VSS 0.05116f
C1471 VDD.n123 VSS 0.02592f
C1472 VDD.t331 VSS 0.10182f
C1473 VDD.t211 VSS 0.10182f
C1474 VDD.n124 VSS 0.05116f
C1475 VDD.n125 VSS 0.01468f
C1476 VDD.t21 VSS 0.10182f
C1477 VDD.t217 VSS 0.10182f
C1478 VDD.n126 VSS 0.05116f
C1479 VDD.n127 VSS 0.01468f
C1480 VDD.t133 VSS 0.10182f
C1481 VDD.t229 VSS 0.10182f
C1482 VDD.n128 VSS 0.05116f
C1483 VDD.n129 VSS 0.01468f
C1484 VDD.t103 VSS 0.10182f
C1485 VDD.t131 VSS 0.10182f
C1486 VDD.n130 VSS 0.05116f
C1487 VDD.n131 VSS 0.01468f
C1488 VDD.t67 VSS 0.10182f
C1489 VDD.t101 VSS 0.10182f
C1490 VDD.n132 VSS 0.05116f
C1491 VDD.n133 VSS 0.01468f
C1492 VDD.t197 VSS 0.10182f
C1493 VDD.t65 VSS 0.10182f
C1494 VDD.n134 VSS 0.05116f
C1495 VDD.n135 VSS 0.01468f
C1496 VDD.t243 VSS 0.10182f
C1497 VDD.t195 VSS 0.10182f
C1498 VDD.n136 VSS 0.05116f
C1499 VDD.n137 VSS 0.01468f
C1500 VDD.t201 VSS 0.10182f
C1501 VDD.t241 VSS 0.10182f
C1502 VDD.n138 VSS 0.05116f
C1503 VDD.n139 VSS 0.01468f
C1504 VDD.t335 VSS 0.10182f
C1505 VDD.t199 VSS 0.10182f
C1506 VDD.n140 VSS 0.05116f
C1507 VDD.n141 VSS 0.01468f
C1508 VDD.t219 VSS 0.10358f
C1509 VDD.t333 VSS 0.10182f
C1510 VDD.n142 VSS 0.05116f
C1511 VDD.n143 VSS 0.05731f
C1512 VDD.n144 VSS 1.79955f
C1513 VDD.t221 VSS 0.10999f
C1514 VDD.t223 VSS 0.11191f
C1515 VDD.n145 VSS 0.05156f
C1516 VDD.t235 VSS 0.10999f
C1517 VDD.t237 VSS 0.10999f
C1518 VDD.n146 VSS 0.05116f
C1519 VDD.n147 VSS 0.02592f
C1520 VDD.t245 VSS 0.10999f
C1521 VDD.t247 VSS 0.10999f
C1522 VDD.n148 VSS 0.05116f
C1523 VDD.n149 VSS 0.01468f
C1524 VDD.t337 VSS 0.11191f
C1525 VDD.t339 VSS 0.10999f
C1526 VDD.n150 VSS 0.05116f
C1527 VDD.n151 VSS 0.05731f
C1528 VDD.n152 VSS 0.80107f
C1529 VDD.t75 VSS 0.10564f
C1530 VDD.t77 VSS 0.10747f
C1531 VDD.n153 VSS 0.05156f
C1532 VDD.t23 VSS 0.10564f
C1533 VDD.t25 VSS 0.10564f
C1534 VDD.n154 VSS 0.05116f
C1535 VDD.n155 VSS 0.02592f
C1536 VDD.t203 VSS 0.10564f
C1537 VDD.t205 VSS 0.10564f
C1538 VDD.n156 VSS 0.05116f
C1539 VDD.n157 VSS 0.01468f
C1540 VDD.t79 VSS 0.10747f
C1541 VDD.t81 VSS 0.10564f
C1542 VDD.n158 VSS 0.05116f
C1543 VDD.n159 VSS 0.05731f
C1544 VDD.n160 VSS 0.55779f
C1545 VDD.t117 VSS 0.08018f
C1546 VDD.t115 VSS 0.08153f
C1547 VDD.n161 VSS 0.05156f
C1548 VDD.t121 VSS 0.08018f
C1549 VDD.t119 VSS 0.08018f
C1550 VDD.n162 VSS 0.05116f
C1551 VDD.n163 VSS 0.02592f
C1552 VDD.t123 VSS 0.08018f
C1553 VDD.t111 VSS 0.08018f
C1554 VDD.n164 VSS 0.05116f
C1555 VDD.n165 VSS 0.01468f
C1556 VDD.t127 VSS 0.08153f
C1557 VDD.t125 VSS 0.08018f
C1558 VDD.n166 VSS 0.05116f
C1559 VDD.n167 VSS 0.05731f
C1560 VDD.n168 VSS 0.55779f
C1561 VDD.t13 VSS 0.06908f
C1562 VDD.t11 VSS 0.07022f
C1563 VDD.n169 VSS 0.05156f
C1564 VDD.t17 VSS 0.07022f
C1565 VDD.t15 VSS 0.06908f
C1566 VDD.n170 VSS 0.05116f
C1567 VDD.n171 VSS 0.06855f
C1568 VDD.n172 VSS 0.49697f
C1569 VDD.t107 VSS 0.08018f
C1570 VDD.t105 VSS 0.08153f
C1571 VDD.n173 VSS 0.05156f
C1572 VDD.t113 VSS 0.08153f
C1573 VDD.t109 VSS 0.08018f
C1574 VDD.n174 VSS 0.05116f
C1575 VDD.n175 VSS 0.06855f
C1576 VDD.n176 VSS 0.56143f
C1577 VDD.n177 VSS 44.2724f
C1578 VDD.n178 VSS 75.2692f
C1579 VDD.n180 VSS 0.01373f
C1580 CLKN_HB.n0 VSS 0.03957f
C1581 CLKN_HB.n1 VSS 0.13671f
C1582 CLKN_HB.n2 VSS 0.06757f
C1583 CLKN_HB.n3 VSS 0.07243f
C1584 CLKN_HB.n4 VSS 0.07243f
C1585 CLKN_HB.n5 VSS 0.07243f
C1586 CLKN_HB.n6 VSS 0.06757f
C1587 CLKN_HB.n7 VSS 0.13671f
C1588 CLKN_HB.n8 VSS 0.07243f
C1589 CLKN_HB.n9 VSS 0.07243f
C1590 CLKN_HB.n10 VSS 0.07243f
C1591 CLKN_HB.n11 VSS 0.03957f
C1592 CLKN_HB.n12 VSS 0.23518f
C1593 CLKN_HB.n13 VSS 0.03957f
C1594 CLKN_HB.n14 VSS 0.13671f
C1595 CLKN_HB.n15 VSS 0.06757f
C1596 CLKN_HB.n16 VSS 0.07243f
C1597 CLKN_HB.n17 VSS 0.07243f
C1598 CLKN_HB.n18 VSS 0.07243f
C1599 CLKN_HB.n19 VSS 0.06757f
C1600 CLKN_HB.n20 VSS 0.13671f
C1601 CLKN_HB.n21 VSS 0.07243f
C1602 CLKN_HB.n22 VSS 0.07243f
C1603 CLKN_HB.n23 VSS 0.07243f
C1604 CLKN_HB.n24 VSS 0.03957f
C1605 CLKN_HB.n25 VSS 0.16162f
C1606 CLKN_HB.n26 VSS 0.99937f
C1607 CLKN_HB.n27 VSS 0.06661f
C1608 CLKN_HB.n28 VSS 0.07243f
C1609 CLKN_HB.n29 VSS 0.07243f
C1610 CLKN_HB.n30 VSS 0.06661f
C1611 CLKN_HB.n31 VSS 0.31796f
C1612 CLKN_HB.n32 VSS 0.06661f
C1613 CLKN_HB.n33 VSS 0.07243f
C1614 CLKN_HB.n34 VSS 0.07243f
C1615 CLKN_HB.n35 VSS 0.06661f
C1616 CLKN_HB.n36 VSS 0.25697f
C1617 CLKN_HB.n37 VSS 0.65633f
C1618 CLKN_HB.n38 VSS 1.29592f
C1619 CLKN_H.n0 VSS 0.05609f
C1620 CLKN_H.n1 VSS 0.06099f
C1621 CLKN_H.n2 VSS 0.06099f
C1622 CLKN_H.n3 VSS 0.05609f
C1623 CLKN_H.n4 VSS 0.26774f
C1624 CLKN_H.n5 VSS 0.05609f
C1625 CLKN_H.n6 VSS 0.06099f
C1626 CLKN_H.n7 VSS 0.06099f
C1627 CLKN_H.n8 VSS 0.05609f
C1628 CLKN_H.n9 VSS 0.21639f
C1629 CLKN_H.n10 VSS 1.63645f
C1630 O_CAPTURE_CLKB.t9 VSS 1.05677f
C1631 O_CAPTURE_CLKB.t10 VSS 0.24611f
C1632 O_CAPTURE_CLKB.t14 VSS 0.24611f
C1633 O_CAPTURE_CLKB.n0 VSS 0.7783f
C1634 O_CAPTURE_CLKB.n1 VSS 0.42781f
C1635 O_CAPTURE_CLKB.t15 VSS 0.24611f
C1636 O_CAPTURE_CLKB.t0 VSS 0.24611f
C1637 O_CAPTURE_CLKB.n2 VSS 0.7783f
C1638 O_CAPTURE_CLKB.n3 VSS 0.22332f
C1639 O_CAPTURE_CLKB.t1 VSS 0.24611f
C1640 O_CAPTURE_CLKB.t7 VSS 0.24611f
C1641 O_CAPTURE_CLKB.n4 VSS 0.7783f
C1642 O_CAPTURE_CLKB.n5 VSS 0.22332f
C1643 O_CAPTURE_CLKB.t8 VSS 1.04979f
C1644 O_CAPTURE_CLKB.n6 VSS 0.46205f
C1645 O_CAPTURE_CLKB.t6 VSS 1.05492f
C1646 O_CAPTURE_CLKB.t13 VSS 0.24611f
C1647 O_CAPTURE_CLKB.t4 VSS 0.24611f
C1648 O_CAPTURE_CLKB.n7 VSS 0.77256f
C1649 O_CAPTURE_CLKB.n8 VSS 0.4354f
C1650 O_CAPTURE_CLKB.t5 VSS 0.24611f
C1651 O_CAPTURE_CLKB.t11 VSS 0.24611f
C1652 O_CAPTURE_CLKB.n9 VSS 0.77256f
C1653 O_CAPTURE_CLKB.n10 VSS 0.22906f
C1654 O_CAPTURE_CLKB.t12 VSS 0.24611f
C1655 O_CAPTURE_CLKB.t2 VSS 0.24611f
C1656 O_CAPTURE_CLKB.n11 VSS 0.77256f
C1657 O_CAPTURE_CLKB.n12 VSS 0.22906f
C1658 O_CAPTURE_CLKB.t3 VSS 1.04792f
C1659 O_CAPTURE_CLKB.n13 VSS 0.3133f
C1660 O_CAPTURE_CLKB.n14 VSS 1.00544f
C1661 O_CAPTURE_CLK.t14 VSS 1.02147f
C1662 O_CAPTURE_CLK.t15 VSS 0.24424f
C1663 O_CAPTURE_CLK.t8 VSS 0.24424f
C1664 O_CAPTURE_CLK.n0 VSS 0.74605f
C1665 O_CAPTURE_CLK.n1 VSS 0.41008f
C1666 O_CAPTURE_CLK.t9 VSS 0.24424f
C1667 O_CAPTURE_CLK.t4 VSS 0.24424f
C1668 O_CAPTURE_CLK.n2 VSS 0.74605f
C1669 O_CAPTURE_CLK.n3 VSS 0.21407f
C1670 O_CAPTURE_CLK.t5 VSS 0.24424f
C1671 O_CAPTURE_CLK.t0 VSS 0.24424f
C1672 O_CAPTURE_CLK.n4 VSS 0.74605f
C1673 O_CAPTURE_CLK.n5 VSS 0.21407f
C1674 O_CAPTURE_CLK.t1 VSS 1.01477f
C1675 O_CAPTURE_CLK.n6 VSS 0.44291f
C1676 O_CAPTURE_CLK.t12 VSS 1.01969f
C1677 O_CAPTURE_CLK.t13 VSS 0.24424f
C1678 O_CAPTURE_CLK.t10 VSS 0.24424f
C1679 O_CAPTURE_CLK.n7 VSS 0.74055f
C1680 O_CAPTURE_CLK.n8 VSS 0.41736f
C1681 O_CAPTURE_CLK.t11 VSS 0.24424f
C1682 O_CAPTURE_CLK.t6 VSS 0.24424f
C1683 O_CAPTURE_CLK.n9 VSS 0.74055f
C1684 O_CAPTURE_CLK.n10 VSS 0.21957f
C1685 O_CAPTURE_CLK.t7 VSS 0.24424f
C1686 O_CAPTURE_CLK.t2 VSS 0.24424f
C1687 O_CAPTURE_CLK.n11 VSS 0.74055f
C1688 O_CAPTURE_CLK.n12 VSS 0.21957f
C1689 O_CAPTURE_CLK.t3 VSS 1.01298f
C1690 O_CAPTURE_CLK.n13 VSS 0.30032f
C1691 O_CAPTURE_CLK.n14 VSS 1.53503f
C1692 O_SENSE.t27 VSS 1.10836f
C1693 O_SENSE.t21 VSS 0.25948f
C1694 O_SENSE.t8 VSS 0.25948f
C1695 O_SENSE.n0 VSS 0.81497f
C1696 O_SENSE.n1 VSS 0.44796f
C1697 O_SENSE.t41 VSS 0.25948f
C1698 O_SENSE.t2 VSS 0.25948f
C1699 O_SENSE.n2 VSS 0.81497f
C1700 O_SENSE.n3 VSS 0.23385f
C1701 O_SENSE.t15 VSS 0.25948f
C1702 O_SENSE.t38 VSS 0.25948f
C1703 O_SENSE.n4 VSS 0.81497f
C1704 O_SENSE.n5 VSS 0.23385f
C1705 O_SENSE.t55 VSS 0.25948f
C1706 O_SENSE.t43 VSS 0.25948f
C1707 O_SENSE.n6 VSS 0.81497f
C1708 O_SENSE.n7 VSS 0.23385f
C1709 O_SENSE.t61 VSS 0.25948f
C1710 O_SENSE.t30 VSS 0.25948f
C1711 O_SENSE.n8 VSS 0.81497f
C1712 O_SENSE.n9 VSS 0.23385f
C1713 O_SENSE.t26 VSS 0.25948f
C1714 O_SENSE.t40 VSS 0.25948f
C1715 O_SENSE.n10 VSS 0.81497f
C1716 O_SENSE.n11 VSS 0.23385f
C1717 O_SENSE.t37 VSS 0.25948f
C1718 O_SENSE.t54 VSS 0.25948f
C1719 O_SENSE.n12 VSS 0.81497f
C1720 O_SENSE.n13 VSS 0.23385f
C1721 O_SENSE.t35 VSS 0.25948f
C1722 O_SENSE.t33 VSS 0.25948f
C1723 O_SENSE.n14 VSS 0.81497f
C1724 O_SENSE.n15 VSS 0.23385f
C1725 O_SENSE.t20 VSS 0.25948f
C1726 O_SENSE.t7 VSS 0.25948f
C1727 O_SENSE.n16 VSS 0.81497f
C1728 O_SENSE.n17 VSS 0.23385f
C1729 O_SENSE.t1 VSS 0.25948f
C1730 O_SENSE.t14 VSS 0.25948f
C1731 O_SENSE.n18 VSS 0.81497f
C1732 O_SENSE.n19 VSS 0.23385f
C1733 O_SENSE.t46 VSS 0.25948f
C1734 O_SENSE.t19 VSS 0.25948f
C1735 O_SENSE.n20 VSS 0.81497f
C1736 O_SENSE.n21 VSS 0.23385f
C1737 O_SENSE.t6 VSS 0.25948f
C1738 O_SENSE.t0 VSS 0.25948f
C1739 O_SENSE.n22 VSS 0.81497f
C1740 O_SENSE.n23 VSS 0.23385f
C1741 O_SENSE.t13 VSS 0.25948f
C1742 O_SENSE.t18 VSS 0.25948f
C1743 O_SENSE.n24 VSS 0.81497f
C1744 O_SENSE.n25 VSS 0.23385f
C1745 O_SENSE.t5 VSS 0.25948f
C1746 O_SENSE.t48 VSS 0.25948f
C1747 O_SENSE.n26 VSS 0.81497f
C1748 O_SENSE.n27 VSS 0.23385f
C1749 O_SENSE.t50 VSS 0.25948f
C1750 O_SENSE.t53 VSS 0.25948f
C1751 O_SENSE.n28 VSS 0.81497f
C1752 O_SENSE.n29 VSS 0.23385f
C1753 O_SENSE.t59 VSS 1.10105f
C1754 O_SENSE.n30 VSS 0.48382f
C1755 O_SENSE.t58 VSS 1.10642f
C1756 O_SENSE.t45 VSS 0.25948f
C1757 O_SENSE.t60 VSS 0.25948f
C1758 O_SENSE.n31 VSS 0.80896f
C1759 O_SENSE.n32 VSS 0.45592f
C1760 O_SENSE.t31 VSS 0.25948f
C1761 O_SENSE.t42 VSS 0.25948f
C1762 O_SENSE.n33 VSS 0.80896f
C1763 O_SENSE.n34 VSS 0.23986f
C1764 O_SENSE.t39 VSS 0.25948f
C1765 O_SENSE.t57 VSS 0.25948f
C1766 O_SENSE.n35 VSS 0.80896f
C1767 O_SENSE.n36 VSS 0.23986f
C1768 O_SENSE.t36 VSS 0.25948f
C1769 O_SENSE.t34 VSS 0.25948f
C1770 O_SENSE.n37 VSS 0.80896f
C1771 O_SENSE.n38 VSS 0.23986f
C1772 O_SENSE.t25 VSS 0.25948f
C1773 O_SENSE.t12 VSS 0.25948f
C1774 O_SENSE.n39 VSS 0.80896f
C1775 O_SENSE.n40 VSS 0.23986f
C1776 O_SENSE.t4 VSS 0.25948f
C1777 O_SENSE.t17 VSS 0.25948f
C1778 O_SENSE.n41 VSS 0.80896f
C1779 O_SENSE.n42 VSS 0.23986f
C1780 O_SENSE.t49 VSS 0.25948f
C1781 O_SENSE.t24 VSS 0.25948f
C1782 O_SENSE.n43 VSS 0.80896f
C1783 O_SENSE.n44 VSS 0.23986f
C1784 O_SENSE.t11 VSS 0.25948f
C1785 O_SENSE.t3 VSS 0.25948f
C1786 O_SENSE.n45 VSS 0.80896f
C1787 O_SENSE.n46 VSS 0.23986f
C1788 O_SENSE.t16 VSS 0.25948f
C1789 O_SENSE.t23 VSS 0.25948f
C1790 O_SENSE.n47 VSS 0.80896f
C1791 O_SENSE.n48 VSS 0.23986f
C1792 O_SENSE.t10 VSS 0.25948f
C1793 O_SENSE.t47 VSS 0.25948f
C1794 O_SENSE.n49 VSS 0.80896f
C1795 O_SENSE.n50 VSS 0.23986f
C1796 O_SENSE.t51 VSS 0.25948f
C1797 O_SENSE.t29 VSS 0.25948f
C1798 O_SENSE.n51 VSS 0.80896f
C1799 O_SENSE.n52 VSS 0.23986f
C1800 O_SENSE.t56 VSS 0.25948f
C1801 O_SENSE.t63 VSS 0.25948f
C1802 O_SENSE.n53 VSS 0.80896f
C1803 O_SENSE.n54 VSS 0.23986f
C1804 O_SENSE.t28 VSS 0.25948f
C1805 O_SENSE.t22 VSS 0.25948f
C1806 O_SENSE.n55 VSS 0.80896f
C1807 O_SENSE.n56 VSS 0.23986f
C1808 O_SENSE.t9 VSS 0.25948f
C1809 O_SENSE.t52 VSS 0.25948f
C1810 O_SENSE.n57 VSS 0.80896f
C1811 O_SENSE.n58 VSS 0.23986f
C1812 O_SENSE.t44 VSS 0.25948f
C1813 O_SENSE.t62 VSS 0.25948f
C1814 O_SENSE.n59 VSS 0.80896f
C1815 O_SENSE.n60 VSS 0.23986f
C1816 O_SENSE.t32 VSS 1.09909f
C1817 O_SENSE.n61 VSS 0.32806f
C1818 O_SENSE.n62 VSS 2.12976f
C1819 CLKP_HB.n0 VSS 0.04016f
C1820 CLKP_HB.n1 VSS 0.13873f
C1821 CLKP_HB.n2 VSS 0.06857f
C1822 CLKP_HB.n3 VSS 0.0735f
C1823 CLKP_HB.n4 VSS 0.0735f
C1824 CLKP_HB.n5 VSS 0.0735f
C1825 CLKP_HB.n6 VSS 0.06857f
C1826 CLKP_HB.n7 VSS 0.13873f
C1827 CLKP_HB.n8 VSS 0.0735f
C1828 CLKP_HB.n9 VSS 0.0735f
C1829 CLKP_HB.n10 VSS 0.0735f
C1830 CLKP_HB.n11 VSS 0.04016f
C1831 CLKP_HB.n12 VSS 0.23866f
C1832 CLKP_HB.n13 VSS 0.04016f
C1833 CLKP_HB.n14 VSS 0.13873f
C1834 CLKP_HB.n15 VSS 0.06857f
C1835 CLKP_HB.n16 VSS 0.0735f
C1836 CLKP_HB.n17 VSS 0.0735f
C1837 CLKP_HB.n18 VSS 0.0735f
C1838 CLKP_HB.n19 VSS 0.06857f
C1839 CLKP_HB.n20 VSS 0.13873f
C1840 CLKP_HB.n21 VSS 0.0735f
C1841 CLKP_HB.n22 VSS 0.0735f
C1842 CLKP_HB.n23 VSS 0.0735f
C1843 CLKP_HB.n24 VSS 0.04016f
C1844 CLKP_HB.n25 VSS 0.16401f
C1845 CLKP_HB.n26 VSS 1.01418f
C1846 CLKP_HB.n27 VSS 0.0676f
C1847 CLKP_HB.n28 VSS 0.0735f
C1848 CLKP_HB.n29 VSS 0.0735f
C1849 CLKP_HB.n30 VSS 0.0676f
C1850 CLKP_HB.n31 VSS 0.32267f
C1851 CLKP_HB.n32 VSS 0.0676f
C1852 CLKP_HB.n33 VSS 0.0735f
C1853 CLKP_HB.n34 VSS 0.0735f
C1854 CLKP_HB.n35 VSS 0.0676f
C1855 CLKP_HB.n36 VSS 0.26078f
C1856 CLKP_HB.n37 VSS 0.66606f
C1857 CLKP_HB.n38 VSS 1.22236f
C1858 CLKP_H.n0 VSS 0.05609f
C1859 CLKP_H.n1 VSS 0.06099f
C1860 CLKP_H.n2 VSS 0.06099f
C1861 CLKP_H.n3 VSS 0.05609f
C1862 CLKP_H.n4 VSS 0.26774f
C1863 CLKP_H.n5 VSS 0.05609f
C1864 CLKP_H.n6 VSS 0.06099f
C1865 CLKP_H.n7 VSS 0.06099f
C1866 CLKP_H.n8 VSS 0.05609f
C1867 CLKP_H.n9 VSS 0.21639f
C1868 CLKP_H.n10 VSS 1.63645f
C1869 E_CAPTURE_CLKB.t15 VSS 1.05677f
C1870 E_CAPTURE_CLKB.t7 VSS 0.24611f
C1871 E_CAPTURE_CLKB.t13 VSS 0.24611f
C1872 E_CAPTURE_CLKB.n0 VSS 0.7783f
C1873 E_CAPTURE_CLKB.n1 VSS 0.42781f
C1874 E_CAPTURE_CLKB.t8 VSS 0.24611f
C1875 E_CAPTURE_CLKB.t10 VSS 0.24611f
C1876 E_CAPTURE_CLKB.n2 VSS 0.7783f
C1877 E_CAPTURE_CLKB.n3 VSS 0.22332f
C1878 E_CAPTURE_CLKB.t9 VSS 0.24611f
C1879 E_CAPTURE_CLKB.t6 VSS 0.24611f
C1880 E_CAPTURE_CLKB.n4 VSS 0.7783f
C1881 E_CAPTURE_CLKB.n5 VSS 0.22332f
C1882 E_CAPTURE_CLKB.t14 VSS 1.04979f
C1883 E_CAPTURE_CLKB.n6 VSS 0.46205f
C1884 E_CAPTURE_CLKB.t3 VSS 1.05492f
C1885 E_CAPTURE_CLKB.t1 VSS 0.24611f
C1886 E_CAPTURE_CLKB.t4 VSS 0.24611f
C1887 E_CAPTURE_CLKB.n7 VSS 0.77256f
C1888 E_CAPTURE_CLKB.n8 VSS 0.4354f
C1889 E_CAPTURE_CLKB.t2 VSS 0.24611f
C1890 E_CAPTURE_CLKB.t0 VSS 0.24611f
C1891 E_CAPTURE_CLKB.n9 VSS 0.77256f
C1892 E_CAPTURE_CLKB.n10 VSS 0.22906f
C1893 E_CAPTURE_CLKB.t12 VSS 0.24611f
C1894 E_CAPTURE_CLKB.t11 VSS 0.24611f
C1895 E_CAPTURE_CLKB.n11 VSS 0.77256f
C1896 E_CAPTURE_CLKB.n12 VSS 0.22906f
C1897 E_CAPTURE_CLKB.t5 VSS 1.04792f
C1898 E_CAPTURE_CLKB.n13 VSS 0.3133f
C1899 E_CAPTURE_CLKB.n14 VSS 1.00544f
C1900 E_CAPTURE_CLK.t6 VSS 1.02147f
C1901 E_CAPTURE_CLK.t14 VSS 0.24424f
C1902 E_CAPTURE_CLK.t3 VSS 0.24424f
C1903 E_CAPTURE_CLK.n0 VSS 0.74605f
C1904 E_CAPTURE_CLK.n1 VSS 0.41008f
C1905 E_CAPTURE_CLK.t7 VSS 0.24424f
C1906 E_CAPTURE_CLK.t13 VSS 0.24424f
C1907 E_CAPTURE_CLK.n2 VSS 0.74605f
C1908 E_CAPTURE_CLK.n3 VSS 0.21407f
C1909 E_CAPTURE_CLK.t9 VSS 0.24424f
C1910 E_CAPTURE_CLK.t10 VSS 0.24424f
C1911 E_CAPTURE_CLK.n4 VSS 0.74605f
C1912 E_CAPTURE_CLK.n5 VSS 0.21407f
C1913 E_CAPTURE_CLK.t4 VSS 1.01477f
C1914 E_CAPTURE_CLK.n6 VSS 0.44291f
C1915 E_CAPTURE_CLK.t0 VSS 1.01969f
C1916 E_CAPTURE_CLK.t12 VSS 0.24424f
C1917 E_CAPTURE_CLK.t11 VSS 0.24424f
C1918 E_CAPTURE_CLK.n7 VSS 0.74055f
C1919 E_CAPTURE_CLK.n8 VSS 0.41736f
C1920 E_CAPTURE_CLK.t8 VSS 0.24424f
C1921 E_CAPTURE_CLK.t1 VSS 0.24424f
C1922 E_CAPTURE_CLK.n9 VSS 0.74055f
C1923 E_CAPTURE_CLK.n10 VSS 0.21957f
C1924 E_CAPTURE_CLK.t5 VSS 0.24424f
C1925 E_CAPTURE_CLK.t15 VSS 0.24424f
C1926 E_CAPTURE_CLK.n11 VSS 0.74055f
C1927 E_CAPTURE_CLK.n12 VSS 0.21957f
C1928 E_CAPTURE_CLK.t2 VSS 1.01298f
C1929 E_CAPTURE_CLK.n13 VSS 0.30032f
C1930 E_CAPTURE_CLK.n14 VSS 1.53503f
C1931 E_SENSE.t23 VSS 1.10836f
C1932 E_SENSE.t52 VSS 0.25948f
C1933 E_SENSE.t53 VSS 0.25948f
C1934 E_SENSE.n0 VSS 0.81497f
C1935 E_SENSE.n1 VSS 0.44796f
C1936 E_SENSE.t36 VSS 0.25948f
C1937 E_SENSE.t37 VSS 0.25948f
C1938 E_SENSE.n2 VSS 0.81497f
C1939 E_SENSE.n3 VSS 0.23385f
C1940 E_SENSE.t4 VSS 0.25948f
C1941 E_SENSE.t5 VSS 0.25948f
C1942 E_SENSE.n4 VSS 0.81497f
C1943 E_SENSE.n5 VSS 0.23385f
C1944 E_SENSE.t20 VSS 0.25948f
C1945 E_SENSE.t21 VSS 0.25948f
C1946 E_SENSE.n6 VSS 0.81497f
C1947 E_SENSE.n7 VSS 0.23385f
C1948 E_SENSE.t50 VSS 0.25948f
C1949 E_SENSE.t51 VSS 0.25948f
C1950 E_SENSE.n8 VSS 0.81497f
C1951 E_SENSE.n9 VSS 0.23385f
C1952 E_SENSE.t62 VSS 0.25948f
C1953 E_SENSE.t63 VSS 0.25948f
C1954 E_SENSE.n10 VSS 0.81497f
C1955 E_SENSE.n11 VSS 0.23385f
C1956 E_SENSE.t34 VSS 0.25948f
C1957 E_SENSE.t35 VSS 0.25948f
C1958 E_SENSE.n12 VSS 0.81497f
C1959 E_SENSE.n13 VSS 0.23385f
C1960 E_SENSE.t2 VSS 0.25948f
C1961 E_SENSE.t3 VSS 0.25948f
C1962 E_SENSE.n14 VSS 0.81497f
C1963 E_SENSE.n15 VSS 0.23385f
C1964 E_SENSE.t18 VSS 0.25948f
C1965 E_SENSE.t19 VSS 0.25948f
C1966 E_SENSE.n16 VSS 0.81497f
C1967 E_SENSE.n17 VSS 0.23385f
C1968 E_SENSE.t48 VSS 0.25948f
C1969 E_SENSE.t49 VSS 0.25948f
C1970 E_SENSE.n18 VSS 0.81497f
C1971 E_SENSE.n19 VSS 0.23385f
C1972 E_SENSE.t60 VSS 0.25948f
C1973 E_SENSE.t61 VSS 0.25948f
C1974 E_SENSE.n20 VSS 0.81497f
C1975 E_SENSE.n21 VSS 0.23385f
C1976 E_SENSE.t32 VSS 0.25948f
C1977 E_SENSE.t33 VSS 0.25948f
C1978 E_SENSE.n22 VSS 0.81497f
C1979 E_SENSE.n23 VSS 0.23385f
C1980 E_SENSE.t0 VSS 0.25948f
C1981 E_SENSE.t1 VSS 0.25948f
C1982 E_SENSE.n24 VSS 0.81497f
C1983 E_SENSE.n25 VSS 0.23385f
C1984 E_SENSE.t16 VSS 0.25948f
C1985 E_SENSE.t17 VSS 0.25948f
C1986 E_SENSE.n26 VSS 0.81497f
C1987 E_SENSE.n27 VSS 0.23385f
C1988 E_SENSE.t46 VSS 0.25948f
C1989 E_SENSE.t47 VSS 0.25948f
C1990 E_SENSE.n28 VSS 0.81497f
C1991 E_SENSE.n29 VSS 0.23385f
C1992 E_SENSE.t31 VSS 1.10105f
C1993 E_SENSE.n30 VSS 0.48382f
C1994 E_SENSE.t30 VSS 1.10642f
C1995 E_SENSE.t14 VSS 0.25948f
C1996 E_SENSE.t15 VSS 0.25948f
C1997 E_SENSE.n31 VSS 0.80896f
C1998 E_SENSE.n32 VSS 0.45592f
C1999 E_SENSE.t44 VSS 0.25948f
C2000 E_SENSE.t45 VSS 0.25948f
C2001 E_SENSE.n33 VSS 0.80896f
C2002 E_SENSE.n34 VSS 0.23986f
C2003 E_SENSE.t12 VSS 0.25948f
C2004 E_SENSE.t13 VSS 0.25948f
C2005 E_SENSE.n35 VSS 0.80896f
C2006 E_SENSE.n36 VSS 0.23986f
C2007 E_SENSE.t28 VSS 0.25948f
C2008 E_SENSE.t29 VSS 0.25948f
C2009 E_SENSE.n37 VSS 0.80896f
C2010 E_SENSE.n38 VSS 0.23986f
C2011 E_SENSE.t58 VSS 0.25948f
C2012 E_SENSE.t59 VSS 0.25948f
C2013 E_SENSE.n39 VSS 0.80896f
C2014 E_SENSE.n40 VSS 0.23986f
C2015 E_SENSE.t42 VSS 0.25948f
C2016 E_SENSE.t43 VSS 0.25948f
C2017 E_SENSE.n41 VSS 0.80896f
C2018 E_SENSE.n42 VSS 0.23986f
C2019 E_SENSE.t10 VSS 0.25948f
C2020 E_SENSE.t11 VSS 0.25948f
C2021 E_SENSE.n43 VSS 0.80896f
C2022 E_SENSE.n44 VSS 0.23986f
C2023 E_SENSE.t26 VSS 0.25948f
C2024 E_SENSE.t27 VSS 0.25948f
C2025 E_SENSE.n45 VSS 0.80896f
C2026 E_SENSE.n46 VSS 0.23986f
C2027 E_SENSE.t56 VSS 0.25948f
C2028 E_SENSE.t57 VSS 0.25948f
C2029 E_SENSE.n47 VSS 0.80896f
C2030 E_SENSE.n48 VSS 0.23986f
C2031 E_SENSE.t40 VSS 0.25948f
C2032 E_SENSE.t41 VSS 0.25948f
C2033 E_SENSE.n49 VSS 0.80896f
C2034 E_SENSE.n50 VSS 0.23986f
C2035 E_SENSE.t8 VSS 0.25948f
C2036 E_SENSE.t9 VSS 0.25948f
C2037 E_SENSE.n51 VSS 0.80896f
C2038 E_SENSE.n52 VSS 0.23986f
C2039 E_SENSE.t24 VSS 0.25948f
C2040 E_SENSE.t25 VSS 0.25948f
C2041 E_SENSE.n53 VSS 0.80896f
C2042 E_SENSE.n54 VSS 0.23986f
C2043 E_SENSE.t54 VSS 0.25948f
C2044 E_SENSE.t55 VSS 0.25948f
C2045 E_SENSE.n55 VSS 0.80896f
C2046 E_SENSE.n56 VSS 0.23986f
C2047 E_SENSE.t38 VSS 0.25948f
C2048 E_SENSE.t39 VSS 0.25948f
C2049 E_SENSE.n57 VSS 0.80896f
C2050 E_SENSE.n58 VSS 0.23986f
C2051 E_SENSE.t6 VSS 0.25948f
C2052 E_SENSE.t7 VSS 0.25948f
C2053 E_SENSE.n59 VSS 0.80896f
C2054 E_SENSE.n60 VSS 0.23986f
C2055 E_SENSE.t22 VSS 1.09909f
C2056 E_SENSE.n61 VSS 0.32806f
C2057 E_SENSE.n62 VSS 2.12976f
.ends
