* PEX produced using /foss/tools/sak/sak-pex.sh with m=3 and s=1 (extresist threshold=0 mOhm, minres=1 mOhm, mindelay=0 ps)
* NGSPICE file created from local_clock_fanout_pex.ext - technology: gf180mcuD

.subckt local_clock_fanout_pex CLKP_H CLKP_HB CLKN_H CLKN_HB VDD VSS E_SENSE E_CAPTURE_CLK
+ E_CAPTURE_CLKB O_SENSE O_CAPTURE_CLK O_CAPTURE_CLKB
X0 O_SENSE.t5 a_15180_41600.t56 VSS.t3 VSS.t2 nfet_03v3 ad=2.08p pd=8.52u as=2.08p ps=8.52u w=8u l=0.28u
X1 E_CAPTURE_CLKB.t7 a_2700_6400.t12 VSS.t187 VSS.t186 nfet_03v3 ad=2.08p pd=8.52u as=2.08p ps=8.52u w=8u l=0.28u
X2 a_6924_41600.t5 CLKN_HB.t2 VSS.t309 VSS.t308 nfet_03v3 ad=2.08p pd=8.52u as=2.08p ps=8.52u w=8u l=0.28u
X3 VDD.t191 a_2700_6400.t21 E_CAPTURE_CLKB.t11 VDD.t190 pfet_03v3 ad=2.08p pd=8.52u as=2.08p ps=8.52u w=8u l=0.28u
X4 VDD.t209 a_15180_6400.t107 E_SENSE.t45 VDD.t208 pfet_03v3 ad=2.08p pd=8.52u as=2.08p ps=8.52u w=8u l=0.28u
X5 VDD.t231 a_2700_41600.t23 O_CAPTURE_CLKB.t7 VDD.t230 pfet_03v3 ad=2.08p pd=8.52u as=3.52p ps=16.88u w=8u l=0.28u
X6 VSS.t17 a_6924_6400.t35 a_15180_6400.t5 VSS.t16 nfet_03v3 ad=2.08p pd=8.52u as=2.08p ps=8.52u w=8u l=0.28u
X7 O_SENSE.t52 a_15180_41600.t112 VDD.t193 VDD.t192 pfet_03v3 ad=2.08p pd=8.52u as=2.08p ps=8.52u w=8u l=0.28u
X8 VSS.t149 a_15180_41600.t65 O_SENSE.t36 VSS.t148 nfet_03v3 ad=2.08p pd=8.52u as=2.08p ps=8.52u w=8u l=0.28u
X9 E_SENSE.t48 a_15180_6400.t62 VSS.t221 VSS.t220 nfet_03v3 ad=2.08p pd=8.52u as=2.08p ps=8.52u w=8u l=0.28u
X10 O_CAPTURE_CLKB.t1 a_2700_41600.t14 VSS.t33 VSS.t32 nfet_03v3 ad=2.08p pd=8.52u as=2.08p ps=8.52u w=8u l=0.28u
X11 a_15180_6400.t36 a_6924_6400.t60 VDD.t139 VDD.t138 pfet_03v3 ad=2.08p pd=8.52u as=2.08p ps=8.52u w=8u l=0.28u
X12 VSS.t9 a_6924_6400.t33 a_15180_6400.t1 VSS.t8 nfet_03v3 ad=2.08p pd=8.52u as=2.08p ps=8.52u w=8u l=0.28u
X13 VSS.t269 CLKP_HB.t5 a_6924_6400.t2 VSS.t268 nfet_03v3 ad=2.08p pd=8.52u as=2.08p ps=8.52u w=8u l=0.28u
X14 VDD.t237 a_15180_41600.t99 O_SENSE.t60 VDD.t236 pfet_03v3 ad=2.08p pd=8.52u as=2.08p ps=8.52u w=8u l=0.28u
X15 a_6924_6400.t9 CLKP_HB.t18 VDD.t265 VDD.t264 pfet_03v3 ad=2.08p pd=8.52u as=2.08p ps=8.52u w=8u l=0.28u
X16 a_15180_6400.t28 a_6924_6400.t58 VDD.t89 VDD.t88 pfet_03v3 ad=2.08p pd=8.52u as=2.08p ps=8.52u w=8u l=0.28u
X17 VDD.t27 a_15180_6400.t99 E_SENSE.t3 VDD.t26 pfet_03v3 ad=2.08p pd=8.52u as=2.08p ps=8.52u w=8u l=0.28u
X18 E_SENSE.t18 a_15180_6400.t60 VSS.t139 VSS.t138 nfet_03v3 ad=2.08p pd=8.52u as=2.08p ps=8.52u w=8u l=0.28u
X19 O_SENSE.t37 a_15180_41600.t62 VSS.t151 VSS.t150 nfet_03v3 ad=2.08p pd=8.52u as=2.08p ps=8.52u w=8u l=0.28u
X20 VDD.t145 a_15180_41600.t85 O_SENSE.t46 VDD.t144 pfet_03v3 ad=2.08p pd=8.52u as=2.08p ps=8.52u w=8u l=0.28u
X21 VSS.t57 a_6924_41600.t21 a_15180_41600.t9 VSS.t56 nfet_03v3 ad=2.08p pd=8.52u as=2.08p ps=8.52u w=8u l=0.28u
X22 E_CAPTURE_CLKB.t8 a_2700_6400.t16 VDD.t161 VDD.t160 pfet_03v3 ad=3.52p pd=16.88u as=2.08p ps=8.52u w=8u l=0.28u
X23 O_SENSE.t48 a_15180_41600.t118 VDD.t165 VDD.t164 pfet_03v3 ad=2.08p pd=8.52u as=2.08p ps=8.52u w=8u l=0.28u
X24 VDD.t253 CLKP_HB.t19 a_6924_6400.t8 VDD.t252 pfet_03v3 ad=2.08p pd=8.52u as=3.52p ps=16.88u w=8u l=0.28u
X25 E_SENSE.t30 a_15180_6400.t100 VDD.t157 VDD.t156 pfet_03v3 ad=2.08p pd=8.52u as=2.08p ps=8.52u w=8u l=0.28u
X26 VSS.t141 a_15180_6400.t61 E_SENSE.t19 VSS.t140 nfet_03v3 ad=2.08p pd=8.52u as=2.08p ps=8.52u w=8u l=0.28u
X27 VSS.t63 a_15180_6400.t83 E_SENSE.t5 VSS.t62 nfet_03v3 ad=2.08p pd=8.52u as=3.52p ps=16.88u w=8u l=0.28u
X28 VDD.t173 a_6924_41600.t43 a_15180_41600.t34 VDD.t172 pfet_03v3 ad=2.08p pd=8.52u as=2.08p ps=8.52u w=8u l=0.28u
X29 VSS.t347 a_15180_41600.t81 O_SENSE.t69 VSS.t346 nfet_03v3 ad=2.08p pd=8.52u as=2.08p ps=8.52u w=8u l=0.28u
X30 VDD.t273 CLKP_HB.t13 a_6924_6400.t14 VDD.t272 pfet_03v3 ad=2.08p pd=8.52u as=2.08p ps=8.52u w=8u l=0.28u
X31 VDD.t11 a_6924_6400.t53 a_15180_6400.t7 VDD.t10 pfet_03v3 ad=2.08p pd=8.52u as=2.08p ps=8.52u w=8u l=0.28u
X32 a_15180_6400.t10 a_6924_6400.t26 VSS.t49 VSS.t48 nfet_03v3 ad=2.08p pd=8.52u as=2.08p ps=8.52u w=8u l=0.28u
X33 O_CAPTURE_CLK.t8 a_4812_41600.t18 VDD.t225 VDD.t224 pfet_03v3 ad=2.08p pd=8.52u as=2.08p ps=8.52u w=8u l=0.28u
X34 a_15180_41600.t6 a_6924_41600.t18 VSS.t29 VSS.t28 nfet_03v3 ad=2.08p pd=8.52u as=2.08p ps=8.52u w=8u l=0.28u
X35 O_SENSE.t63 a_15180_41600.t68 VSS.t321 VSS.t320 nfet_03v3 ad=2.08p pd=8.52u as=2.08p ps=8.52u w=8u l=0.28u
X36 VDD.t189 a_2700_6400.t17 E_CAPTURE_CLKB.t10 VDD.t188 pfet_03v3 ad=2.08p pd=8.52u as=2.08p ps=8.52u w=8u l=0.28u
X37 VDD.t241 a_6924_6400.t51 a_15180_6400.t43 VDD.t240 pfet_03v3 ad=2.08p pd=8.52u as=2.08p ps=8.52u w=8u l=0.28u
X38 VSS.t363 a_15180_6400.t53 E_SENSE.t71 VSS.t362 nfet_03v3 ad=2.08p pd=8.52u as=2.08p ps=8.52u w=8u l=0.28u
X39 E_CAPTURE_CLK.t9 a_4812_6400.t12 VSS.t203 VSS.t202 nfet_03v3 ad=2.08p pd=8.52u as=2.08p ps=8.52u w=8u l=0.28u
X40 a_15180_41600.t43 a_6924_41600.t40 VDD.t321 VDD.t320 pfet_03v3 ad=3.52p pd=16.88u as=2.08p ps=8.52u w=8u l=0.28u
X41 VDD.t7 a_15180_41600.t91 O_SENSE.t3 VDD.t6 pfet_03v3 ad=2.08p pd=8.52u as=2.08p ps=8.52u w=8u l=0.28u
X42 a_15180_41600.t0 a_6924_41600.t62 VDD.t13 VDD.t12 pfet_03v3 ad=2.08p pd=8.52u as=2.08p ps=8.52u w=8u l=0.28u
X43 VSS.t23 a_6924_41600.t27 a_15180_41600.t3 VSS.t22 nfet_03v3 ad=2.08p pd=8.52u as=2.08p ps=8.52u w=8u l=0.28u
X44 O_CAPTURE_CLKB.t15 a_2700_41600.t20 VDD.t365 VDD.t364 pfet_03v3 ad=2.08p pd=8.52u as=2.08p ps=8.52u w=8u l=0.28u
X45 O_SENSE.t28 a_15180_41600.t54 VSS.t121 VSS.t120 nfet_03v3 ad=2.08p pd=8.52u as=2.08p ps=8.52u w=8u l=0.28u
X46 a_6924_6400.t13 CLKP_HB.t14 VDD.t271 VDD.t270 pfet_03v3 ad=2.08p pd=8.52u as=2.08p ps=8.52u w=8u l=0.28u
X47 a_15180_6400.t26 a_6924_6400.t54 VDD.t85 VDD.t84 pfet_03v3 ad=2.08p pd=8.52u as=2.08p ps=8.52u w=8u l=0.28u
X48 E_SENSE.t34 a_15180_6400.t56 VSS.t197 VSS.t196 nfet_03v3 ad=2.08p pd=8.52u as=2.08p ps=8.52u w=8u l=0.28u
X49 a_6924_41600.t7 CLKN_HB.t0 VSS.t311 VSS.t310 nfet_03v3 ad=3.52p pd=16.88u as=2.08p ps=8.52u w=8u l=0.28u
X50 VDD.t353 a_15180_6400.t93 E_SENSE.t65 VDD.t352 pfet_03v3 ad=2.08p pd=8.52u as=2.08p ps=8.52u w=8u l=0.28u
X51 E_SENSE.t42 a_15180_6400.t54 VSS.t209 VSS.t208 nfet_03v3 ad=2.08p pd=8.52u as=2.08p ps=8.52u w=8u l=0.28u
X52 O_SENSE.t42 a_15180_41600.t88 VDD.t131 VDD.t130 pfet_03v3 ad=2.08p pd=8.52u as=2.08p ps=8.52u w=8u l=0.28u
X53 VSS.t171 a_2700_41600.t11 O_CAPTURE_CLKB.t6 VSS.t170 nfet_03v3 ad=2.08p pd=8.52u as=2.08p ps=8.52u w=8u l=0.28u
X54 a_6924_6400.t15 CLKP_HB.t12 VDD.t275 VDD.t274 pfet_03v3 ad=3.52p pd=16.88u as=2.08p ps=8.52u w=8u l=0.28u
X55 a_15180_6400.t6 a_6924_6400.t52 VDD.t9 VDD.t8 pfet_03v3 ad=2.08p pd=8.52u as=2.08p ps=8.52u w=8u l=0.28u
X56 VSS.t163 a_4812_6400.t13 E_CAPTURE_CLK.t5 VSS.t162 nfet_03v3 ad=2.08p pd=8.52u as=2.08p ps=8.52u w=8u l=0.28u
X57 VDD.t69 a_6924_41600.t59 a_15180_41600.t15 VDD.t68 pfet_03v3 ad=2.08p pd=8.52u as=2.08p ps=8.52u w=8u l=0.28u
X58 O_SENSE.t45 a_15180_41600.t110 VDD.t143 VDD.t142 pfet_03v3 ad=2.08p pd=8.52u as=2.08p ps=8.52u w=8u l=0.28u
X59 a_15180_41600.t14 a_6924_41600.t24 VSS.t89 VSS.t88 nfet_03v3 ad=2.08p pd=8.52u as=2.08p ps=8.52u w=8u l=0.28u
X60 E_CAPTURE_CLK.t0 a_4812_6400.t22 VDD.t15 VDD.t14 pfet_03v3 ad=2.08p pd=8.52u as=2.08p ps=8.52u w=8u l=0.28u
X61 VDD.t213 a_15180_6400.t91 E_SENSE.t47 VDD.t212 pfet_03v3 ad=2.08p pd=8.52u as=2.08p ps=8.52u w=8u l=0.28u
X62 VSS.t217 a_4812_6400.t11 E_CAPTURE_CLK.t10 VSS.t216 nfet_03v3 ad=2.08p pd=8.52u as=2.08p ps=8.52u w=8u l=0.28u
X63 VDD.t233 a_2700_41600.t17 O_CAPTURE_CLKB.t8 VDD.t232 pfet_03v3 ad=2.08p pd=8.52u as=2.08p ps=8.52u w=8u l=0.28u
X64 a_15180_41600.t32 a_6924_41600.t46 VDD.t151 VDD.t150 pfet_03v3 ad=2.08p pd=8.52u as=2.08p ps=8.52u w=8u l=0.28u
X65 a_4812_41600.t1 CLKN_H.t2 VSS.t283 VSS.t282 nfet_03v3 ad=2.08p pd=8.52u as=2.08p ps=8.52u w=8u l=0.28u
X66 VSS.t5 a_15180_41600.t51 O_SENSE.t6 VSS.t4 nfet_03v3 ad=2.08p pd=8.52u as=2.08p ps=8.52u w=8u l=0.28u
X67 a_15180_6400.t44 a_6924_6400.t46 VDD.t243 VDD.t242 pfet_03v3 ad=2.08p pd=8.52u as=2.08p ps=8.52u w=8u l=0.28u
X68 VSS.t85 a_6924_6400.t19 a_15180_6400.t21 VSS.t84 nfet_03v3 ad=2.08p pd=8.52u as=2.08p ps=8.52u w=8u l=0.28u
X69 VSS.t245 a_4812_41600.t15 O_CAPTURE_CLK.t9 VSS.t244 nfet_03v3 ad=2.08p pd=8.52u as=3.52p ps=16.88u w=8u l=0.28u
X70 a_4812_41600.t7 CLKN_H.t4 VDD.t283 VDD.t282 pfet_03v3 ad=3.52p pd=16.88u as=2.08p ps=8.52u w=8u l=0.28u
X71 O_SENSE.t58 a_15180_41600.t60 VSS.t237 VSS.t236 nfet_03v3 ad=2.08p pd=8.52u as=2.08p ps=8.52u w=8u l=0.28u
X72 VSS.t355 a_15180_6400.t77 E_SENSE.t67 VSS.t354 nfet_03v3 ad=2.08p pd=8.52u as=2.08p ps=8.52u w=8u l=0.28u
X73 E_CAPTURE_CLKB.t2 a_2700_6400.t14 VSS.t69 VSS.t68 nfet_03v3 ad=2.08p pd=8.52u as=2.08p ps=8.52u w=8u l=0.28u
X74 VDD.t185 a_4812_41600.t21 O_CAPTURE_CLK.t1 VDD.t184 pfet_03v3 ad=2.08p pd=8.52u as=2.08p ps=8.52u w=8u l=0.28u
X75 VDD.t119 a_15180_41600.t107 O_SENSE.t40 VDD.t118 pfet_03v3 ad=2.08p pd=8.52u as=2.08p ps=8.52u w=8u l=0.28u
X76 VSS.t293 CLKN_HB.t9 a_2700_41600.t2 VSS.t292 nfet_03v3 ad=2.08p pd=8.52u as=2.08p ps=8.52u w=8u l=0.28u
X77 a_6924_41600.t1 CLKN_HB.t6 VSS.t301 VSS.t300 nfet_03v3 ad=2.08p pd=8.52u as=2.08p ps=8.52u w=8u l=0.28u
X78 VDD.t251 a_2700_6400.t23 E_CAPTURE_CLKB.t13 VDD.t250 pfet_03v3 ad=2.08p pd=8.52u as=3.52p ps=16.88u w=8u l=0.28u
X79 O_SENSE.t23 a_15180_41600.t94 VDD.t81 VDD.t80 pfet_03v3 ad=2.08p pd=8.52u as=2.08p ps=8.52u w=8u l=0.28u
X80 VDD.t17 a_4812_6400.t23 E_CAPTURE_CLK.t1 VDD.t16 pfet_03v3 ad=2.08p pd=8.52u as=3.52p ps=16.88u w=8u l=0.28u
X81 E_SENSE.t60 a_15180_6400.t114 VDD.t343 VDD.t342 pfet_03v3 ad=2.08p pd=8.52u as=2.08p ps=8.52u w=8u l=0.28u
X82 a_2700_6400.t1 CLKP_HB.t10 VSS.t261 VSS.t260 nfet_03v3 ad=2.08p pd=8.52u as=2.08p ps=8.52u w=8u l=0.28u
X83 a_6924_41600.t11 CLKN_HB.t16 VDD.t299 VDD.t298 pfet_03v3 ad=2.08p pd=8.52u as=2.08p ps=8.52u w=8u l=0.28u
X84 O_SENSE.t20 a_15180_41600.t116 VDD.t59 VDD.t58 pfet_03v3 ad=2.08p pd=8.52u as=2.08p ps=8.52u w=8u l=0.28u
X85 VDD.t255 CLKP_HB.t23 a_2700_6400.t4 VDD.t254 pfet_03v3 ad=2.08p pd=8.52u as=3.52p ps=16.88u w=8u l=0.28u
X86 VDD.t245 a_6924_6400.t47 a_15180_6400.t45 VDD.t244 pfet_03v3 ad=2.08p pd=8.52u as=2.08p ps=8.52u w=8u l=0.28u
X87 a_15180_6400.t24 a_6924_6400.t20 VSS.t99 VSS.t98 nfet_03v3 ad=2.08p pd=8.52u as=2.08p ps=8.52u w=8u l=0.28u
X88 a_2700_6400.t3 CLKP_HB.t8 VSS.t265 VSS.t264 nfet_03v3 ad=3.52p pd=16.88u as=2.08p ps=8.52u w=8u l=0.28u
X89 VSS.t75 a_15180_41600.t57 O_SENSE.t18 VSS.t74 nfet_03v3 ad=2.08p pd=8.52u as=2.08p ps=8.52u w=8u l=0.28u
X90 VDD.t41 a_6924_6400.t45 a_15180_6400.t15 VDD.t40 pfet_03v3 ad=2.08p pd=8.52u as=2.08p ps=8.52u w=8u l=0.28u
X91 E_SENSE.t22 a_15180_6400.t86 VDD.t109 VDD.t108 pfet_03v3 ad=2.08p pd=8.52u as=2.08p ps=8.52u w=8u l=0.28u
X92 VSS.t307 CLKN_HB.t3 a_6924_41600.t4 VSS.t306 nfet_03v3 ad=2.08p pd=8.52u as=2.08p ps=8.52u w=8u l=0.28u
X93 VSS.t331 a_15180_41600.t79 O_SENSE.t67 VSS.t330 nfet_03v3 ad=2.08p pd=8.52u as=2.08p ps=8.52u w=8u l=0.28u
X94 VDD.t75 a_15180_6400.t117 E_SENSE.t9 VDD.t74 pfet_03v3 ad=2.08p pd=8.52u as=2.08p ps=8.52u w=8u l=0.28u
X95 VDD.t345 a_15180_6400.t115 E_SENSE.t61 VDD.t344 pfet_03v3 ad=2.08p pd=8.52u as=2.08p ps=8.52u w=8u l=0.28u
X96 a_4812_6400.t3 CLKP_H.t0 VSS.t317 VSS.t316 nfet_03v3 ad=3.52p pd=16.88u as=2.08p ps=8.52u w=8u l=0.28u
X97 E_SENSE.t52 a_15180_6400.t84 VDD.t323 VDD.t322 pfet_03v3 ad=3.52p pd=16.88u as=2.08p ps=8.52u w=8u l=0.28u
X98 VDD.t305 CLKN_HB.t13 a_6924_41600.t14 VDD.t304 pfet_03v3 ad=2.08p pd=8.52u as=2.08p ps=8.52u w=8u l=0.28u
X99 VDD.t113 a_15180_41600.t113 O_SENSE.t38 VDD.t112 pfet_03v3 ad=2.08p pd=8.52u as=2.08p ps=8.52u w=8u l=0.28u
X100 VSS.t329 a_2700_41600.t15 O_CAPTURE_CLKB.t12 VSS.t328 nfet_03v3 ad=2.08p pd=8.52u as=3.52p ps=16.88u w=8u l=0.28u
X101 VSS.t263 CLKP_HB.t9 a_2700_6400.t2 VSS.t262 nfet_03v3 ad=2.08p pd=8.52u as=2.08p ps=8.52u w=8u l=0.28u
X102 O_SENSE.t4 a_15180_41600.t76 VSS.t1 VSS.t0 nfet_03v3 ad=2.08p pd=8.52u as=2.08p ps=8.52u w=8u l=0.28u
X103 E_SENSE.t6 a_15180_6400.t70 VSS.t65 VSS.t64 nfet_03v3 ad=2.08p pd=8.52u as=2.08p ps=8.52u w=8u l=0.28u
X104 VSS.t313 CLKP_H.t3 a_4812_6400.t0 VSS.t312 nfet_03v3 ad=2.08p pd=8.52u as=3.52p ps=16.88u w=8u l=0.28u
X105 VDD.t111 a_15180_6400.t87 E_SENSE.t23 VDD.t110 pfet_03v3 ad=2.08p pd=8.52u as=2.08p ps=8.52u w=8u l=0.28u
X106 VDD.t325 a_15180_6400.t85 E_SENSE.t53 VDD.t324 pfet_03v3 ad=2.08p pd=8.52u as=2.08p ps=8.52u w=8u l=0.28u
X107 VSS.t333 a_15180_41600.t63 O_SENSE.t68 VSS.t332 nfet_03v3 ad=2.08p pd=8.52u as=2.08p ps=8.52u w=8u l=0.28u
X108 E_CAPTURE_CLK.t13 a_4812_6400.t16 VDD.t317 VDD.t316 pfet_03v3 ad=3.52p pd=16.88u as=2.08p ps=8.52u w=8u l=0.28u
X109 VSS.t319 CLKP_H.t1 a_4812_6400.t2 VSS.t318 nfet_03v3 ad=2.08p pd=8.52u as=2.08p ps=8.52u w=8u l=0.28u
X110 a_4812_6400.t5 CLKP_H.t6 VDD.t311 VDD.t310 pfet_03v3 ad=2.08p pd=8.52u as=2.08p ps=8.52u w=8u l=0.28u
X111 a_15180_6400.t8 a_6924_6400.t40 VDD.t35 VDD.t34 pfet_03v3 ad=3.52p pd=16.88u as=2.08p ps=8.52u w=8u l=0.28u
X112 a_2700_41600.t5 CLKN_HB.t22 VDD.t287 VDD.t286 pfet_03v3 ad=2.08p pd=8.52u as=2.08p ps=8.52u w=8u l=0.28u
X113 VDD.t61 a_6924_41600.t57 a_15180_41600.t11 VDD.t60 pfet_03v3 ad=2.08p pd=8.52u as=2.08p ps=8.52u w=8u l=0.28u
X114 VDD.t1 a_15180_41600.t119 O_SENSE.t0 VDD.t0 pfet_03v3 ad=2.08p pd=8.52u as=3.52p ps=16.88u w=8u l=0.28u
X115 VSS.t123 a_15180_41600.t49 O_SENSE.t29 VSS.t122 nfet_03v3 ad=2.08p pd=8.52u as=2.08p ps=8.52u w=8u l=0.28u
X116 VSS.t67 a_15180_6400.t71 E_SENSE.t7 VSS.t66 nfet_03v3 ad=2.08p pd=8.52u as=2.08p ps=8.52u w=8u l=0.28u
X117 VSS.t93 a_2700_6400.t13 E_CAPTURE_CLKB.t5 VSS.t92 nfet_03v3 ad=2.08p pd=8.52u as=2.08p ps=8.52u w=8u l=0.28u
X118 E_SENSE.t62 a_15180_6400.t108 VDD.t347 VDD.t346 pfet_03v3 ad=2.08p pd=8.52u as=2.08p ps=8.52u w=8u l=0.28u
X119 O_SENSE.t39 a_15180_41600.t82 VSS.t161 VSS.t160 nfet_03v3 ad=2.08p pd=8.52u as=2.08p ps=8.52u w=8u l=0.28u
X120 a_15180_6400.t30 a_6924_6400.t36 VSS.t125 VSS.t124 nfet_03v3 ad=2.08p pd=8.52u as=2.08p ps=8.52u w=8u l=0.28u
X121 VDD.t355 a_4812_41600.t19 O_CAPTURE_CLK.t13 VDD.t354 pfet_03v3 ad=2.08p pd=8.52u as=2.08p ps=8.52u w=8u l=0.28u
X122 a_15180_41600.t23 a_6924_41600.t54 VDD.t117 VDD.t116 pfet_03v3 ad=2.08p pd=8.52u as=2.08p ps=8.52u w=8u l=0.28u
X123 VSS.t175 a_6924_41600.t19 a_15180_41600.t28 VSS.t174 nfet_03v3 ad=2.08p pd=8.52u as=2.08p ps=8.52u w=8u l=0.28u
X124 VSS.t223 a_15180_6400.t63 E_SENSE.t49 VSS.t222 nfet_03v3 ad=2.08p pd=8.52u as=2.08p ps=8.52u w=8u l=0.28u
X125 VDD.t141 a_6924_6400.t61 a_15180_6400.t37 VDD.t140 pfet_03v3 ad=2.08p pd=8.52u as=2.08p ps=8.52u w=8u l=0.28u
X126 a_15180_6400.t4 a_6924_6400.t34 VSS.t15 VSS.t14 nfet_03v3 ad=2.08p pd=8.52u as=2.08p ps=8.52u w=8u l=0.28u
X127 a_6924_6400.t1 CLKP_HB.t6 VSS.t267 VSS.t266 nfet_03v3 ad=2.08p pd=8.52u as=2.08p ps=8.52u w=8u l=0.28u
X128 VDD.t201 a_6924_41600.t41 a_15180_41600.t38 VDD.t200 pfet_03v3 ad=2.08p pd=8.52u as=2.08p ps=8.52u w=8u l=0.28u
X129 O_CAPTURE_CLK.t6 a_4812_41600.t10 VSS.t235 VSS.t234 nfet_03v3 ad=2.08p pd=8.52u as=2.08p ps=8.52u w=8u l=0.28u
X130 VDD.t147 a_6924_41600.t63 a_15180_41600.t30 VDD.t146 pfet_03v3 ad=2.08p pd=8.52u as=3.52p ps=16.88u w=8u l=0.28u
X131 VDD.t127 a_2700_41600.t21 O_CAPTURE_CLKB.t4 VDD.t126 pfet_03v3 ad=2.08p pd=8.52u as=2.08p ps=8.52u w=8u l=0.28u
X132 O_CAPTURE_CLK.t10 a_4812_41600.t16 VDD.t229 VDD.t228 pfet_03v3 ad=3.52p pd=16.88u as=2.08p ps=8.52u w=8u l=0.28u
X133 O_SENSE.t32 a_15180_41600.t102 VDD.t97 VDD.t96 pfet_03v3 ad=2.08p pd=8.52u as=2.08p ps=8.52u w=8u l=0.28u
X134 a_15180_41600.t21 a_6924_41600.t16 VSS.t111 VSS.t110 nfet_03v3 ad=3.52p pd=16.88u as=2.08p ps=8.52u w=8u l=0.28u
X135 VSS.t45 a_15180_41600.t55 O_SENSE.t13 VSS.t44 nfet_03v3 ad=2.08p pd=8.52u as=2.08p ps=8.52u w=8u l=0.28u
X136 E_CAPTURE_CLKB.t0 a_2700_6400.t8 VSS.t37 VSS.t36 nfet_03v3 ad=3.52p pd=16.88u as=2.08p ps=8.52u w=8u l=0.28u
X137 VDD.t83 a_15180_41600.t89 O_SENSE.t24 VDD.t82 pfet_03v3 ad=2.08p pd=8.52u as=2.08p ps=8.52u w=8u l=0.28u
X138 a_15180_41600.t2 a_6924_41600.t38 VSS.t21 VSS.t20 nfet_03v3 ad=2.08p pd=8.52u as=2.08p ps=8.52u w=8u l=0.28u
X139 E_SENSE.t68 a_15180_6400.t64 VSS.t357 VSS.t356 nfet_03v3 ad=2.08p pd=8.52u as=2.08p ps=8.52u w=8u l=0.28u
X140 O_CAPTURE_CLKB.t2 a_2700_41600.t12 VSS.t35 VSS.t34 nfet_03v3 ad=2.08p pd=8.52u as=2.08p ps=8.52u w=8u l=0.28u
X141 a_15180_6400.t34 a_6924_6400.t62 VDD.t135 VDD.t134 pfet_03v3 ad=2.08p pd=8.52u as=2.08p ps=8.52u w=8u l=0.28u
X142 VSS.t259 CLKP_HB.t7 a_6924_6400.t0 VSS.t258 nfet_03v3 ad=2.08p pd=8.52u as=3.52p ps=16.88u w=8u l=0.28u
X143 a_15180_41600.t16 a_6924_41600.t60 VDD.t71 VDD.t70 pfet_03v3 ad=2.08p pd=8.52u as=2.08p ps=8.52u w=8u l=0.28u
X144 VDD.t159 a_15180_6400.t101 E_SENSE.t31 VDD.t158 pfet_03v3 ad=2.08p pd=8.52u as=2.08p ps=8.52u w=8u l=0.28u
X145 O_CAPTURE_CLKB.t9 a_2700_41600.t18 VDD.t235 VDD.t234 pfet_03v3 ad=2.08p pd=8.52u as=2.08p ps=8.52u w=8u l=0.28u
X146 O_SENSE.t19 a_15180_41600.t52 VSS.t77 VSS.t76 nfet_03v3 ad=2.08p pd=8.52u as=2.08p ps=8.52u w=8u l=0.28u
X147 VSS.t81 a_6924_6400.t29 a_15180_6400.t19 VSS.t80 nfet_03v3 ad=2.08p pd=8.52u as=2.08p ps=8.52u w=8u l=0.28u
X148 VSS.t277 CLKP_HB.t1 a_6924_6400.t6 VSS.t276 nfet_03v3 ad=2.08p pd=8.52u as=2.08p ps=8.52u w=8u l=0.28u
X149 O_SENSE.t66 a_15180_41600.t86 VDD.t333 VDD.t332 pfet_03v3 ad=2.08p pd=8.52u as=2.08p ps=8.52u w=8u l=0.28u
X150 VSS.t103 a_6924_41600.t35 a_15180_41600.t17 VSS.t102 nfet_03v3 ad=2.08p pd=8.52u as=2.08p ps=8.52u w=8u l=0.28u
X151 O_SENSE.t10 a_15180_41600.t74 VSS.t39 VSS.t38 nfet_03v3 ad=2.08p pd=8.52u as=2.08p ps=8.52u w=8u l=0.28u
X152 VSS.t51 a_6924_6400.t27 a_15180_6400.t11 VSS.t50 nfet_03v3 ad=2.08p pd=8.52u as=2.08p ps=8.52u w=8u l=0.28u
X153 VSS.t181 a_2700_6400.t9 E_CAPTURE_CLKB.t6 VSS.t180 nfet_03v3 ad=2.08p pd=8.52u as=2.08p ps=8.52u w=8u l=0.28u
X154 O_CAPTURE_CLK.t2 a_4812_41600.t22 VDD.t187 VDD.t186 pfet_03v3 ad=2.08p pd=8.52u as=2.08p ps=8.52u w=8u l=0.28u
X155 VSS.t247 a_2700_41600.t9 O_CAPTURE_CLKB.t10 VSS.t246 nfet_03v3 ad=2.08p pd=8.52u as=2.08p ps=8.52u w=8u l=0.28u
X156 E_CAPTURE_CLKB.t9 a_2700_6400.t18 VDD.t163 VDD.t162 pfet_03v3 ad=2.08p pd=8.52u as=2.08p ps=8.52u w=8u l=0.28u
X157 O_SENSE.t31 a_15180_41600.t108 VDD.t95 VDD.t94 pfet_03v3 ad=2.08p pd=8.52u as=2.08p ps=8.52u w=8u l=0.28u
X158 a_15180_41600.t10 a_6924_41600.t22 VSS.t59 VSS.t58 nfet_03v3 ad=2.08p pd=8.52u as=2.08p ps=8.52u w=8u l=0.28u
X159 a_2700_41600.t7 CLKN_HB.t20 VDD.t293 VDD.t292 pfet_03v3 ad=3.52p pd=16.88u as=2.08p ps=8.52u w=8u l=0.28u
X160 a_4812_41600.t3 CLKN_H.t0 VSS.t285 VSS.t284 nfet_03v3 ad=3.52p pd=16.88u as=2.08p ps=8.52u w=8u l=0.28u
X161 E_SENSE.t56 a_15180_6400.t102 VDD.t339 VDD.t338 pfet_03v3 ad=2.08p pd=8.52u as=2.08p ps=8.52u w=8u l=0.28u
X162 VSS.t365 a_4812_41600.t13 O_CAPTURE_CLK.t11 VSS.t364 nfet_03v3 ad=2.08p pd=8.52u as=2.08p ps=8.52u w=8u l=0.28u
X163 VSS.t165 a_15180_41600.t71 O_SENSE.t41 VSS.t164 nfet_03v3 ad=2.08p pd=8.52u as=2.08p ps=8.52u w=8u l=0.28u
X164 a_15180_6400.t22 a_6924_6400.t30 VSS.t95 VSS.t94 nfet_03v3 ad=2.08p pd=8.52u as=2.08p ps=8.52u w=8u l=0.28u
X165 a_6924_6400.t5 CLKP_HB.t2 VSS.t275 VSS.t274 nfet_03v3 ad=2.08p pd=8.52u as=2.08p ps=8.52u w=8u l=0.28u
X166 O_SENSE.t27 a_15180_41600.t58 VSS.t119 VSS.t118 nfet_03v3 ad=2.08p pd=8.52u as=2.08p ps=8.52u w=8u l=0.28u
X167 VDD.t269 CLKP_HB.t15 a_6924_6400.t12 VDD.t268 pfet_03v3 ad=2.08p pd=8.52u as=2.08p ps=8.52u w=8u l=0.28u
X168 VDD.t87 a_6924_6400.t55 a_15180_6400.t27 VDD.t86 pfet_03v3 ad=2.08p pd=8.52u as=2.08p ps=8.52u w=8u l=0.28u
X169 VSS.t199 a_15180_6400.t57 E_SENSE.t35 VSS.t198 nfet_03v3 ad=2.08p pd=8.52u as=2.08p ps=8.52u w=8u l=0.28u
X170 a_15180_6400.t18 a_6924_6400.t28 VSS.t79 VSS.t78 nfet_03v3 ad=2.08p pd=8.52u as=2.08p ps=8.52u w=8u l=0.28u
X171 a_6924_6400.t7 CLKP_HB.t0 VSS.t279 VSS.t278 nfet_03v3 ad=3.52p pd=16.88u as=2.08p ps=8.52u w=8u l=0.28u
X172 VDD.t319 a_15180_41600.t105 O_SENSE.t62 VDD.t318 pfet_03v3 ad=2.08p pd=8.52u as=2.08p ps=8.52u w=8u l=0.28u
X173 a_6924_41600.t3 CLKN_HB.t4 VSS.t303 VSS.t302 nfet_03v3 ad=2.08p pd=8.52u as=2.08p ps=8.52u w=8u l=0.28u
X174 O_SENSE.t54 a_15180_41600.t80 VSS.t213 VSS.t212 nfet_03v3 ad=2.08p pd=8.52u as=2.08p ps=8.52u w=8u l=0.28u
X175 VDD.t49 a_2700_6400.t19 E_CAPTURE_CLKB.t1 VDD.t48 pfet_03v3 ad=2.08p pd=8.52u as=2.08p ps=8.52u w=8u l=0.28u
X176 E_SENSE.t10 a_15180_6400.t94 VDD.t77 VDD.t76 pfet_03v3 ad=2.08p pd=8.52u as=2.08p ps=8.52u w=8u l=0.28u
X177 VSS.t211 a_15180_6400.t55 E_SENSE.t43 VSS.t210 nfet_03v3 ad=2.08p pd=8.52u as=2.08p ps=8.52u w=8u l=0.28u
X178 E_CAPTURE_CLK.t7 a_4812_6400.t14 VSS.t179 VSS.t178 nfet_03v3 ad=2.08p pd=8.52u as=2.08p ps=8.52u w=8u l=0.28u
X179 a_15180_41600.t25 a_6924_41600.t52 VDD.t123 VDD.t122 pfet_03v3 ad=2.08p pd=8.52u as=2.08p ps=8.52u w=8u l=0.28u
X180 O_SENSE.t30 a_15180_41600.t114 VDD.t93 VDD.t92 pfet_03v3 ad=2.08p pd=8.52u as=2.08p ps=8.52u w=8u l=0.28u
X181 a_15180_6400.t2 a_6924_6400.t22 VSS.t11 VSS.t10 nfet_03v3 ad=2.08p pd=8.52u as=2.08p ps=8.52u w=8u l=0.28u
X182 VSS.t305 CLKN_HB.t1 a_6924_41600.t6 VSS.t304 nfet_03v3 ad=2.08p pd=8.52u as=2.08p ps=8.52u w=8u l=0.28u
X183 VSS.t73 a_15180_41600.t77 O_SENSE.t17 VSS.t72 nfet_03v3 ad=2.08p pd=8.52u as=2.08p ps=8.52u w=8u l=0.28u
X184 VDD.t79 a_15180_6400.t95 E_SENSE.t11 VDD.t78 pfet_03v3 ad=2.08p pd=8.52u as=2.08p ps=8.52u w=8u l=0.28u
X185 E_SENSE.t24 a_15180_6400.t78 VSS.t153 VSS.t152 nfet_03v3 ad=2.08p pd=8.52u as=2.08p ps=8.52u w=8u l=0.28u
X186 VSS.t345 a_2700_6400.t15 E_CAPTURE_CLKB.t14 VSS.t344 nfet_03v3 ad=2.08p pd=8.52u as=3.52p ps=16.88u w=8u l=0.28u
X187 VDD.t197 a_6924_41600.t49 a_15180_41600.t36 VDD.t196 pfet_03v3 ad=2.08p pd=8.52u as=2.08p ps=8.52u w=8u l=0.28u
X188 VDD.t329 a_15180_41600.t111 O_SENSE.t64 VDD.t328 pfet_03v3 ad=2.08p pd=8.52u as=2.08p ps=8.52u w=8u l=0.28u
X189 VSS.t13 a_6924_6400.t23 a_15180_6400.t3 VSS.t12 nfet_03v3 ad=2.08p pd=8.52u as=2.08p ps=8.52u w=8u l=0.28u
X190 VSS.t113 a_4812_6400.t15 E_CAPTURE_CLK.t4 VSS.t112 nfet_03v3 ad=2.08p pd=8.52u as=3.52p ps=16.88u w=8u l=0.28u
X191 VSS.t257 CLKP_HB.t11 a_2700_6400.t0 VSS.t256 nfet_03v3 ad=2.08p pd=8.52u as=3.52p ps=16.88u w=8u l=0.28u
X192 VDD.t289 CLKN_HB.t23 a_2700_41600.t4 VDD.t288 pfet_03v3 ad=2.08p pd=8.52u as=3.52p ps=16.88u w=8u l=0.28u
X193 a_15180_41600.t12 a_6924_41600.t58 VDD.t63 VDD.t62 pfet_03v3 ad=2.08p pd=8.52u as=2.08p ps=8.52u w=8u l=0.28u
X194 a_15180_6400.t46 a_6924_6400.t48 VDD.t247 VDD.t246 pfet_03v3 ad=2.08p pd=8.52u as=2.08p ps=8.52u w=8u l=0.28u
X195 E_SENSE.t50 a_15180_6400.t50 VSS.t225 VSS.t224 nfet_03v3 ad=2.08p pd=8.52u as=2.08p ps=8.52u w=8u l=0.28u
X196 VSS.t101 a_6924_6400.t21 a_15180_6400.t25 VSS.t100 nfet_03v3 ad=2.08p pd=8.52u as=2.08p ps=8.52u w=8u l=0.28u
X197 VDD.t51 a_15180_41600.t97 O_SENSE.t15 VDD.t50 pfet_03v3 ad=2.08p pd=8.52u as=2.08p ps=8.52u w=8u l=0.28u
X198 E_SENSE.t54 a_15180_6400.t48 VSS.t325 VSS.t324 nfet_03v3 ad=3.52p pd=16.88u as=2.08p ps=8.52u w=8u l=0.28u
X199 VSS.t131 a_15180_6400.t81 E_SENSE.t13 VSS.t130 nfet_03v3 ad=2.08p pd=8.52u as=2.08p ps=8.52u w=8u l=0.28u
X200 VDD.t285 CLKN_HB.t19 a_6924_41600.t8 VDD.t284 pfet_03v3 ad=2.08p pd=8.52u as=3.52p ps=16.88u w=8u l=0.28u
X201 a_2700_41600.t1 CLKN_HB.t10 VSS.t289 VSS.t288 nfet_03v3 ad=2.08p pd=8.52u as=2.08p ps=8.52u w=8u l=0.28u
X202 E_SENSE.t0 a_15180_6400.t118 VDD.t21 VDD.t20 pfet_03v3 ad=2.08p pd=8.52u as=2.08p ps=8.52u w=8u l=0.28u
X203 VSS.t155 a_15180_6400.t79 E_SENSE.t25 VSS.t154 nfet_03v3 ad=2.08p pd=8.52u as=2.08p ps=8.52u w=8u l=0.28u
X204 O_SENSE.t50 a_15180_41600.t84 VDD.t169 VDD.t168 pfet_03v3 ad=3.52p pd=16.88u as=2.08p ps=8.52u w=8u l=0.28u
X205 VSS.t167 a_6924_41600.t33 a_15180_41600.t26 VSS.t166 nfet_03v3 ad=2.08p pd=8.52u as=2.08p ps=8.52u w=8u l=0.28u
X206 VSS.t145 a_15180_41600.t83 O_SENSE.t34 VSS.t144 nfet_03v3 ad=2.08p pd=8.52u as=3.52p ps=16.88u w=8u l=0.28u
X207 E_SENSE.t8 a_15180_6400.t116 VDD.t73 VDD.t72 pfet_03v3 ad=2.08p pd=8.52u as=2.08p ps=8.52u w=8u l=0.28u
X208 VDD.t43 a_6924_41600.t55 a_15180_41600.t7 VDD.t42 pfet_03v3 ad=2.08p pd=8.52u as=2.08p ps=8.52u w=8u l=0.28u
X209 VDD.t249 a_6924_6400.t49 a_15180_6400.t47 VDD.t248 pfet_03v3 ad=2.08p pd=8.52u as=2.08p ps=8.52u w=8u l=0.28u
X210 VSS.t227 a_15180_6400.t51 E_SENSE.t51 VSS.t226 nfet_03v3 ad=2.08p pd=8.52u as=2.08p ps=8.52u w=8u l=0.28u
X211 VSS.t229 a_4812_41600.t11 O_CAPTURE_CLK.t3 VSS.t228 nfet_03v3 ad=2.08p pd=8.52u as=2.08p ps=8.52u w=8u l=0.28u
X212 E_SENSE.t20 a_15180_6400.t88 VDD.t105 VDD.t104 pfet_03v3 ad=2.08p pd=8.52u as=2.08p ps=8.52u w=8u l=0.28u
X213 VSS.t327 a_15180_6400.t49 E_SENSE.t55 VSS.t326 nfet_03v3 ad=2.08p pd=8.52u as=2.08p ps=8.52u w=8u l=0.28u
X214 E_CAPTURE_CLK.t14 a_4812_6400.t8 VSS.t339 VSS.t338 nfet_03v3 ad=3.52p pd=16.88u as=2.08p ps=8.52u w=8u l=0.28u
X215 a_15180_41600.t41 a_6924_41600.t30 VSS.t253 VSS.t252 nfet_03v3 ad=2.08p pd=8.52u as=2.08p ps=8.52u w=8u l=0.28u
X216 a_15180_6400.t12 a_6924_6400.t16 VSS.t53 VSS.t52 nfet_03v3 ad=3.52p pd=16.88u as=2.08p ps=8.52u w=8u l=0.28u
X217 VDD.t223 a_4812_41600.t17 O_CAPTURE_CLK.t7 VDD.t222 pfet_03v3 ad=2.08p pd=8.52u as=2.08p ps=8.52u w=8u l=0.28u
X218 VDD.t67 a_15180_41600.t103 O_SENSE.t22 VDD.t66 pfet_03v3 ad=2.08p pd=8.52u as=2.08p ps=8.52u w=8u l=0.28u
X219 VSS.t27 a_6924_41600.t17 a_15180_41600.t5 VSS.t26 nfet_03v3 ad=2.08p pd=8.52u as=2.08p ps=8.52u w=8u l=0.28u
X220 VDD.t205 a_4812_6400.t17 E_CAPTURE_CLK.t11 VDD.t204 pfet_03v3 ad=2.08p pd=8.52u as=2.08p ps=8.52u w=8u l=0.28u
X221 a_4812_6400.t1 CLKP_H.t2 VSS.t315 VSS.t314 nfet_03v3 ad=2.08p pd=8.52u as=2.08p ps=8.52u w=8u l=0.28u
X222 VSS.t323 a_6924_41600.t39 a_15180_41600.t42 VSS.t322 nfet_03v3 ad=2.08p pd=8.52u as=3.52p ps=16.88u w=8u l=0.28u
X223 VDD.t37 a_6924_6400.t41 a_15180_6400.t9 VDD.t36 pfet_03v3 ad=2.08p pd=8.52u as=2.08p ps=8.52u w=8u l=0.28u
X224 VSS.t31 a_2700_41600.t13 O_CAPTURE_CLKB.t0 VSS.t30 nfet_03v3 ad=2.08p pd=8.52u as=2.08p ps=8.52u w=8u l=0.28u
X225 O_CAPTURE_CLK.t0 a_4812_41600.t8 VSS.t143 VSS.t142 nfet_03v3 ad=3.52p pd=16.88u as=2.08p ps=8.52u w=8u l=0.28u
X226 O_SENSE.t26 a_15180_41600.t66 VSS.t117 VSS.t116 nfet_03v3 ad=2.08p pd=8.52u as=2.08p ps=8.52u w=8u l=0.28u
X227 VDD.t171 a_6924_41600.t61 a_15180_41600.t33 VDD.t170 pfet_03v3 ad=2.08p pd=8.52u as=2.08p ps=8.52u w=8u l=0.28u
X228 VDD.t179 a_15180_6400.t111 E_SENSE.t37 VDD.t178 pfet_03v3 ad=2.08p pd=8.52u as=2.08p ps=8.52u w=8u l=0.28u
X229 E_SENSE.t40 a_15180_6400.t72 VSS.t205 VSS.t204 nfet_03v3 ad=2.08p pd=8.52u as=2.08p ps=8.52u w=8u l=0.28u
X230 O_SENSE.t33 a_15180_41600.t100 VDD.t99 VDD.t98 pfet_03v3 ad=2.08p pd=8.52u as=2.08p ps=8.52u w=8u l=0.28u
X231 VSS.t243 a_15180_41600.t53 O_SENSE.t59 VSS.t242 nfet_03v3 ad=2.08p pd=8.52u as=2.08p ps=8.52u w=8u l=0.28u
X232 VDD.t349 a_15180_6400.t109 E_SENSE.t63 VDD.t348 pfet_03v3 ad=2.08p pd=8.52u as=2.08p ps=8.52u w=8u l=0.28u
X233 a_15180_41600.t18 a_6924_41600.t36 VSS.t105 VSS.t104 nfet_03v3 ad=2.08p pd=8.52u as=2.08p ps=8.52u w=8u l=0.28u
X234 E_CAPTURE_CLK.t6 a_4812_6400.t18 VDD.t125 VDD.t124 pfet_03v3 ad=2.08p pd=8.52u as=2.08p ps=8.52u w=8u l=0.28u
X235 a_15180_6400.t16 a_6924_6400.t42 VDD.t55 VDD.t54 pfet_03v3 ad=2.08p pd=8.52u as=2.08p ps=8.52u w=8u l=0.28u
X236 VSS.t127 a_6924_6400.t37 a_15180_6400.t31 VSS.t126 nfet_03v3 ad=2.08p pd=8.52u as=2.08p ps=8.52u w=8u l=0.28u
X237 VDD.t277 CLKN_H.t7 a_4812_41600.t4 VDD.t276 pfet_03v3 ad=2.08p pd=8.52u as=3.52p ps=16.88u w=8u l=0.28u
X238 VDD.t167 a_15180_41600.t109 O_SENSE.t49 VDD.t166 pfet_03v3 ad=2.08p pd=8.52u as=2.08p ps=8.52u w=8u l=0.28u
X239 O_CAPTURE_CLKB.t3 a_2700_41600.t10 VSS.t137 VSS.t136 nfet_03v3 ad=2.08p pd=8.52u as=2.08p ps=8.52u w=8u l=0.28u
X240 O_CAPTURE_CLKB.t13 a_2700_41600.t16 VDD.t327 VDD.t326 pfet_03v3 ad=3.52p pd=16.88u as=2.08p ps=8.52u w=8u l=0.28u
X241 O_SENSE.t14 a_15180_41600.t50 VSS.t47 VSS.t46 nfet_03v3 ad=2.08p pd=8.52u as=2.08p ps=8.52u w=8u l=0.28u
X242 E_SENSE.t28 a_15180_6400.t112 VDD.t153 VDD.t152 pfet_03v3 ad=2.08p pd=8.52u as=2.08p ps=8.52u w=8u l=0.28u
X243 O_CAPTURE_CLK.t12 a_4812_41600.t14 VSS.t367 VSS.t366 nfet_03v3 ad=2.08p pd=8.52u as=2.08p ps=8.52u w=8u l=0.28u
X244 O_SENSE.t35 a_15180_41600.t72 VSS.t147 VSS.t146 nfet_03v3 ad=2.08p pd=8.52u as=2.08p ps=8.52u w=8u l=0.28u
X245 E_SENSE.t36 a_15180_6400.t110 VDD.t177 VDD.t176 pfet_03v3 ad=2.08p pd=8.52u as=2.08p ps=8.52u w=8u l=0.28u
X246 O_CAPTURE_CLK.t14 a_4812_41600.t20 VDD.t357 VDD.t356 pfet_03v3 ad=2.08p pd=8.52u as=2.08p ps=8.52u w=8u l=0.28u
X247 a_15180_41600.t35 a_6924_41600.t44 VDD.t175 VDD.t174 pfet_03v3 ad=2.08p pd=8.52u as=2.08p ps=8.52u w=8u l=0.28u
X248 O_SENSE.t53 a_15180_41600.t106 VDD.t195 VDD.t194 pfet_03v3 ad=2.08p pd=8.52u as=2.08p ps=8.52u w=8u l=0.28u
X249 a_2700_41600.t3 CLKN_HB.t8 VSS.t297 VSS.t296 nfet_03v3 ad=3.52p pd=16.88u as=2.08p ps=8.52u w=8u l=0.28u
X250 a_15180_6400.t38 a_6924_6400.t38 VSS.t239 VSS.t238 nfet_03v3 ad=2.08p pd=8.52u as=2.08p ps=8.52u w=8u l=0.28u
X251 E_SENSE.t16 a_15180_6400.t104 VDD.t101 VDD.t100 pfet_03v3 ad=2.08p pd=8.52u as=2.08p ps=8.52u w=8u l=0.28u
X252 VSS.t359 a_15180_6400.t65 E_SENSE.t69 VSS.t358 nfet_03v3 ad=2.08p pd=8.52u as=2.08p ps=8.52u w=8u l=0.28u
X253 VDD.t137 a_6924_6400.t63 a_15180_6400.t35 VDD.t136 pfet_03v3 ad=2.08p pd=8.52u as=3.52p ps=16.88u w=8u l=0.28u
X254 VSS.t215 a_15180_41600.t69 O_SENSE.t55 VSS.t214 nfet_03v3 ad=2.08p pd=8.52u as=2.08p ps=8.52u w=8u l=0.28u
X255 a_15180_41600.t4 a_6924_41600.t28 VSS.t25 VSS.t24 nfet_03v3 ad=2.08p pd=8.52u as=2.08p ps=8.52u w=8u l=0.28u
X256 O_SENSE.t47 a_15180_41600.t78 VSS.t189 VSS.t188 nfet_03v3 ad=2.08p pd=8.52u as=2.08p ps=8.52u w=8u l=0.28u
X257 E_CAPTURE_CLKB.t4 a_2700_6400.t10 VSS.t91 VSS.t90 nfet_03v3 ad=2.08p pd=8.52u as=2.08p ps=8.52u w=8u l=0.28u
X258 VDD.t103 a_15180_6400.t105 E_SENSE.t17 VDD.t102 pfet_03v3 ad=2.08p pd=8.52u as=2.08p ps=8.52u w=8u l=0.28u
X259 E_SENSE.t26 a_15180_6400.t66 VSS.t157 VSS.t156 nfet_03v3 ad=2.08p pd=8.52u as=2.08p ps=8.52u w=8u l=0.28u
X260 a_15180_41600.t37 a_6924_41600.t50 VDD.t199 VDD.t198 pfet_03v3 ad=2.08p pd=8.52u as=2.08p ps=8.52u w=8u l=0.28u
X261 VDD.t341 a_15180_6400.t103 E_SENSE.t57 VDD.t340 pfet_03v3 ad=2.08p pd=8.52u as=2.08p ps=8.52u w=8u l=0.28u
X262 VSS.t107 a_6924_41600.t25 a_15180_41600.t19 VSS.t106 nfet_03v3 ad=2.08p pd=8.52u as=2.08p ps=8.52u w=8u l=0.28u
X263 VSS.t201 a_15180_41600.t75 O_SENSE.t51 VSS.t200 nfet_03v3 ad=2.08p pd=8.52u as=2.08p ps=8.52u w=8u l=0.28u
X264 VSS.t97 a_6924_6400.t31 a_15180_6400.t23 VSS.t96 nfet_03v3 ad=2.08p pd=8.52u as=2.08p ps=8.52u w=8u l=0.28u
X265 VSS.t273 CLKP_HB.t3 a_6924_6400.t4 VSS.t272 nfet_03v3 ad=2.08p pd=8.52u as=2.08p ps=8.52u w=8u l=0.28u
X266 a_6924_6400.t11 CLKP_HB.t16 VDD.t267 VDD.t266 pfet_03v3 ad=2.08p pd=8.52u as=2.08p ps=8.52u w=8u l=0.28u
X267 a_15180_6400.t40 a_6924_6400.t56 VDD.t219 VDD.t218 pfet_03v3 ad=2.08p pd=8.52u as=2.08p ps=8.52u w=8u l=0.28u
X268 E_SENSE.t58 a_15180_6400.t58 VSS.t341 VSS.t340 nfet_03v3 ad=2.08p pd=8.52u as=2.08p ps=8.52u w=8u l=0.28u
X269 VSS.t71 a_2700_6400.t11 E_CAPTURE_CLKB.t3 VSS.t70 nfet_03v3 ad=2.08p pd=8.52u as=2.08p ps=8.52u w=8u l=0.28u
X270 VDD.t335 a_6924_41600.t47 a_15180_41600.t44 VDD.t334 pfet_03v3 ad=2.08p pd=8.52u as=2.08p ps=8.52u w=8u l=0.28u
X271 VSS.t291 CLKN_HB.t11 a_2700_41600.t0 VSS.t290 nfet_03v3 ad=2.08p pd=8.52u as=3.52p ps=16.88u w=8u l=0.28u
X272 a_15180_41600.t27 a_6924_41600.t34 VSS.t169 VSS.t168 nfet_03v3 ad=2.08p pd=8.52u as=2.08p ps=8.52u w=8u l=0.28u
X273 E_CAPTURE_CLKB.t15 a_2700_6400.t20 VDD.t361 VDD.t360 pfet_03v3 ad=2.08p pd=8.52u as=2.08p ps=8.52u w=8u l=0.28u
X274 VDD.t281 CLKN_H.t5 a_4812_41600.t6 VDD.t280 pfet_03v3 ad=2.08p pd=8.52u as=2.08p ps=8.52u w=8u l=0.28u
X275 a_15180_41600.t8 a_6924_41600.t56 VDD.t45 VDD.t44 pfet_03v3 ad=2.08p pd=8.52u as=2.08p ps=8.52u w=8u l=0.28u
X276 VSS.t249 a_15180_41600.t61 O_SENSE.t61 VSS.t248 nfet_03v3 ad=2.08p pd=8.52u as=2.08p ps=8.52u w=8u l=0.28u
X277 VDD.t31 a_15180_41600.t95 O_SENSE.t8 VDD.t30 pfet_03v3 ad=2.08p pd=8.52u as=2.08p ps=8.52u w=8u l=0.28u
X278 VSS.t295 CLKN_HB.t7 a_6924_41600.t0 VSS.t294 nfet_03v3 ad=2.08p pd=8.52u as=3.52p ps=16.88u w=8u l=0.28u
X279 O_SENSE.t43 a_15180_41600.t48 VSS.t173 VSS.t172 nfet_03v3 ad=3.52p pd=16.88u as=2.08p ps=8.52u w=8u l=0.28u
X280 VDD.t91 a_6924_6400.t59 a_15180_6400.t29 VDD.t90 pfet_03v3 ad=2.08p pd=8.52u as=2.08p ps=8.52u w=8u l=0.28u
X281 VDD.t295 CLKN_HB.t17 a_6924_41600.t10 VDD.t294 pfet_03v3 ad=2.08p pd=8.52u as=2.08p ps=8.52u w=8u l=0.28u
X282 VSS.t335 a_6924_41600.t31 a_15180_41600.t46 VSS.t334 nfet_03v3 ad=2.08p pd=8.52u as=2.08p ps=8.52u w=8u l=0.28u
X283 VDD.t263 CLKP_HB.t17 a_6924_6400.t10 VDD.t262 pfet_03v3 ad=2.08p pd=8.52u as=2.08p ps=8.52u w=8u l=0.28u
X284 VDD.t221 a_6924_6400.t57 a_15180_6400.t41 VDD.t220 pfet_03v3 ad=2.08p pd=8.52u as=2.08p ps=8.52u w=8u l=0.28u
X285 E_SENSE.t2 a_15180_6400.t98 VDD.t25 VDD.t24 pfet_03v3 ad=2.08p pd=8.52u as=2.08p ps=8.52u w=8u l=0.28u
X286 VSS.t343 a_15180_6400.t59 E_SENSE.t59 VSS.t342 nfet_03v3 ad=2.08p pd=8.52u as=2.08p ps=8.52u w=8u l=0.28u
X287 E_SENSE.t38 a_15180_6400.t96 VDD.t181 VDD.t180 pfet_03v3 ad=2.08p pd=8.52u as=2.08p ps=8.52u w=8u l=0.28u
X288 VDD.t115 a_6924_41600.t53 a_15180_41600.t22 VDD.t114 pfet_03v3 ad=2.08p pd=8.52u as=2.08p ps=8.52u w=8u l=0.28u
X289 a_15180_6400.t32 a_6924_6400.t24 VSS.t183 VSS.t182 nfet_03v3 ad=2.08p pd=8.52u as=2.08p ps=8.52u w=8u l=0.28u
X290 O_SENSE.t16 a_15180_41600.t92 VDD.t53 VDD.t52 pfet_03v3 ad=2.08p pd=8.52u as=2.08p ps=8.52u w=8u l=0.28u
X291 a_6924_41600.t13 CLKN_HB.t14 VDD.t303 VDD.t302 pfet_03v3 ad=2.08p pd=8.52u as=2.08p ps=8.52u w=8u l=0.28u
X292 VSS.t233 a_4812_41600.t9 O_CAPTURE_CLK.t5 VSS.t232 nfet_03v3 ad=2.08p pd=8.52u as=2.08p ps=8.52u w=8u l=0.28u
X293 VSS.t41 a_15180_41600.t67 O_SENSE.t11 VSS.t40 nfet_03v3 ad=2.08p pd=8.52u as=2.08p ps=8.52u w=8u l=0.28u
X294 E_SENSE.t4 a_15180_6400.t82 VSS.t61 VSS.t60 nfet_03v3 ad=2.08p pd=8.52u as=2.08p ps=8.52u w=8u l=0.28u
X295 VDD.t331 a_15180_41600.t101 O_SENSE.t65 VDD.t330 pfet_03v3 ad=2.08p pd=8.52u as=2.08p ps=8.52u w=8u l=0.28u
X296 VDD.t23 a_15180_6400.t119 E_SENSE.t1 VDD.t22 pfet_03v3 ad=2.08p pd=8.52u as=3.52p ps=16.88u w=8u l=0.28u
X297 VDD.t183 a_15180_6400.t97 E_SENSE.t39 VDD.t182 pfet_03v3 ad=2.08p pd=8.52u as=2.08p ps=8.52u w=8u l=0.28u
X298 E_SENSE.t12 a_15180_6400.t80 VSS.t129 VSS.t128 nfet_03v3 ad=2.08p pd=8.52u as=2.08p ps=8.52u w=8u l=0.28u
X299 O_CAPTURE_CLKB.t5 a_2700_41600.t22 VDD.t129 VDD.t128 pfet_03v3 ad=2.08p pd=8.52u as=2.08p ps=8.52u w=8u l=0.28u
X300 VSS.t19 a_6924_41600.t37 a_15180_41600.t1 VSS.t18 nfet_03v3 ad=2.08p pd=8.52u as=2.08p ps=8.52u w=8u l=0.28u
X301 VSS.t185 a_6924_6400.t25 a_15180_6400.t33 VSS.t184 nfet_03v3 ad=2.08p pd=8.52u as=2.08p ps=8.52u w=8u l=0.28u
X302 O_SENSE.t71 a_15180_41600.t64 VSS.t351 VSS.t350 nfet_03v3 ad=2.08p pd=8.52u as=2.08p ps=8.52u w=8u l=0.28u
X303 a_15180_6400.t42 a_6924_6400.t50 VDD.t239 VDD.t238 pfet_03v3 ad=2.08p pd=8.52u as=2.08p ps=8.52u w=8u l=0.28u
X304 E_SENSE.t70 a_15180_6400.t52 VSS.t361 VSS.t360 nfet_03v3 ad=2.08p pd=8.52u as=2.08p ps=8.52u w=8u l=0.28u
X305 O_SENSE.t56 a_15180_41600.t98 VDD.t215 VDD.t214 pfet_03v3 ad=2.08p pd=8.52u as=2.08p ps=8.52u w=8u l=0.28u
X306 VSS.t281 CLKN_H.t3 a_4812_41600.t0 VSS.t280 nfet_03v3 ad=2.08p pd=8.52u as=3.52p ps=16.88u w=8u l=0.28u
X307 E_CAPTURE_CLK.t2 a_4812_6400.t20 VDD.t19 VDD.t18 pfet_03v3 ad=2.08p pd=8.52u as=2.08p ps=8.52u w=8u l=0.28u
X308 VDD.t107 a_15180_6400.t89 E_SENSE.t21 VDD.t106 pfet_03v3 ad=2.08p pd=8.52u as=2.08p ps=8.52u w=8u l=0.28u
X309 VSS.t191 a_4812_6400.t9 E_CAPTURE_CLK.t8 VSS.t190 nfet_03v3 ad=2.08p pd=8.52u as=2.08p ps=8.52u w=8u l=0.28u
X310 VSS.t115 a_15180_41600.t73 O_SENSE.t25 VSS.t114 nfet_03v3 ad=2.08p pd=8.52u as=2.08p ps=8.52u w=8u l=0.28u
X311 VSS.t55 a_6924_6400.t17 a_15180_6400.t13 VSS.t54 nfet_03v3 ad=2.08p pd=8.52u as=2.08p ps=8.52u w=8u l=0.28u
X312 VDD.t149 a_6924_41600.t45 a_15180_41600.t31 VDD.t148 pfet_03v3 ad=2.08p pd=8.52u as=2.08p ps=8.52u w=8u l=0.28u
X313 O_CAPTURE_CLKB.t11 a_2700_41600.t8 VSS.t255 VSS.t254 nfet_03v3 ad=3.52p pd=16.88u as=2.08p ps=8.52u w=8u l=0.28u
X314 E_SENSE.t64 a_15180_6400.t92 VDD.t351 VDD.t350 pfet_03v3 ad=2.08p pd=8.52u as=2.08p ps=8.52u w=8u l=0.28u
X315 VSS.t195 a_15180_6400.t75 E_SENSE.t33 VSS.t194 nfet_03v3 ad=2.08p pd=8.52u as=2.08p ps=8.52u w=8u l=0.28u
X316 O_CAPTURE_CLK.t4 a_4812_41600.t12 VSS.t231 VSS.t230 nfet_03v3 ad=2.08p pd=8.52u as=2.08p ps=8.52u w=8u l=0.28u
X317 a_15180_41600.t29 a_6924_41600.t20 VSS.t177 VSS.t176 nfet_03v3 ad=2.08p pd=8.52u as=2.08p ps=8.52u w=8u l=0.28u
X318 VDD.t65 a_15180_41600.t117 O_SENSE.t21 VDD.t64 pfet_03v3 ad=2.08p pd=8.52u as=2.08p ps=8.52u w=8u l=0.28u
X319 O_SENSE.t70 a_15180_41600.t70 VSS.t349 VSS.t348 nfet_03v3 ad=2.08p pd=8.52u as=2.08p ps=8.52u w=8u l=0.28u
X320 VDD.t367 a_4812_6400.t21 E_CAPTURE_CLK.t15 VDD.t366 pfet_03v3 ad=2.08p pd=8.52u as=2.08p ps=8.52u w=8u l=0.28u
X321 E_SENSE.t46 a_15180_6400.t90 VDD.t211 VDD.t210 pfet_03v3 ad=2.08p pd=8.52u as=2.08p ps=8.52u w=8u l=0.28u
X322 VSS.t207 a_15180_6400.t73 E_SENSE.t41 VSS.t206 nfet_03v3 ad=2.08p pd=8.52u as=2.08p ps=8.52u w=8u l=0.28u
X323 E_CAPTURE_CLK.t12 a_4812_6400.t10 VSS.t219 VSS.t218 nfet_03v3 ad=2.08p pd=8.52u as=2.08p ps=8.52u w=8u l=0.28u
X324 a_15180_41600.t39 a_6924_41600.t42 VDD.t203 VDD.t202 pfet_03v3 ad=2.08p pd=8.52u as=2.08p ps=8.52u w=8u l=0.28u
X325 O_SENSE.t1 a_15180_41600.t104 VDD.t3 VDD.t2 pfet_03v3 ad=2.08p pd=8.52u as=2.08p ps=8.52u w=8u l=0.28u
X326 a_15180_6400.t20 a_6924_6400.t18 VSS.t83 VSS.t82 nfet_03v3 ad=2.08p pd=8.52u as=2.08p ps=8.52u w=8u l=0.28u
X327 VDD.t47 a_4812_6400.t19 E_CAPTURE_CLK.t3 VDD.t46 pfet_03v3 ad=2.08p pd=8.52u as=2.08p ps=8.52u w=8u l=0.28u
X328 VDD.t57 a_6924_6400.t43 a_15180_6400.t17 VDD.t56 pfet_03v3 ad=2.08p pd=8.52u as=2.08p ps=8.52u w=8u l=0.28u
X329 E_SENSE.t66 a_15180_6400.t76 VSS.t353 VSS.t352 nfet_03v3 ad=2.08p pd=8.52u as=2.08p ps=8.52u w=8u l=0.28u
X330 VDD.t121 a_6924_41600.t51 a_15180_41600.t24 VDD.t120 pfet_03v3 ad=2.08p pd=8.52u as=2.08p ps=8.52u w=8u l=0.28u
X331 E_CAPTURE_CLKB.t12 a_2700_6400.t22 VDD.t227 VDD.t226 pfet_03v3 ad=2.08p pd=8.52u as=2.08p ps=8.52u w=8u l=0.28u
X332 O_SENSE.t9 a_15180_41600.t90 VDD.t33 VDD.t32 pfet_03v3 ad=2.08p pd=8.52u as=2.08p ps=8.52u w=8u l=0.28u
X333 VDD.t155 a_15180_6400.t113 E_SENSE.t29 VDD.t154 pfet_03v3 ad=2.08p pd=8.52u as=2.08p ps=8.52u w=8u l=0.28u
X334 E_SENSE.t32 a_15180_6400.t74 VSS.t193 VSS.t192 nfet_03v3 ad=2.08p pd=8.52u as=2.08p ps=8.52u w=8u l=0.28u
X335 a_6924_41600.t15 CLKN_HB.t12 VDD.t307 VDD.t306 pfet_03v3 ad=3.52p pd=16.88u as=2.08p ps=8.52u w=8u l=0.28u
X336 a_15180_41600.t20 a_6924_41600.t26 VSS.t109 VSS.t108 nfet_03v3 ad=2.08p pd=8.52u as=2.08p ps=8.52u w=8u l=0.28u
X337 a_2700_6400.t5 CLKP_HB.t22 VDD.t257 VDD.t256 pfet_03v3 ad=2.08p pd=8.52u as=2.08p ps=8.52u w=8u l=0.28u
X338 VDD.t363 a_2700_41600.t19 O_CAPTURE_CLKB.t14 VDD.t362 pfet_03v3 ad=2.08p pd=8.52u as=2.08p ps=8.52u w=8u l=0.28u
X339 a_2700_6400.t7 CLKP_HB.t20 VDD.t261 VDD.t260 pfet_03v3 ad=3.52p pd=16.88u as=2.08p ps=8.52u w=8u l=0.28u
X340 a_15180_6400.t14 a_6924_6400.t44 VDD.t39 VDD.t38 pfet_03v3 ad=2.08p pd=8.52u as=2.08p ps=8.52u w=8u l=0.28u
X341 E_SENSE.t14 a_15180_6400.t68 VSS.t133 VSS.t132 nfet_03v3 ad=2.08p pd=8.52u as=2.08p ps=8.52u w=8u l=0.28u
X342 VSS.t241 a_6924_6400.t39 a_15180_6400.t39 VSS.t240 nfet_03v3 ad=2.08p pd=8.52u as=3.52p ps=16.88u w=8u l=0.28u
X343 a_15180_41600.t45 a_6924_41600.t48 VDD.t337 VDD.t336 pfet_03v3 ad=2.08p pd=8.52u as=2.08p ps=8.52u w=8u l=0.28u
X344 a_4812_41600.t5 CLKN_H.t6 VDD.t279 VDD.t278 pfet_03v3 ad=2.08p pd=8.52u as=2.08p ps=8.52u w=8u l=0.28u
X345 VDD.t133 a_15180_41600.t87 O_SENSE.t44 VDD.t132 pfet_03v3 ad=2.08p pd=8.52u as=2.08p ps=8.52u w=8u l=0.28u
X346 VDD.t359 a_4812_41600.t23 O_CAPTURE_CLK.t15 VDD.t358 pfet_03v3 ad=2.08p pd=8.52u as=3.52p ps=16.88u w=8u l=0.28u
X347 VSS.t87 a_6924_41600.t23 a_15180_41600.t13 VSS.t86 nfet_03v3 ad=2.08p pd=8.52u as=2.08p ps=8.52u w=8u l=0.28u
X348 a_4812_6400.t7 CLKP_H.t4 VDD.t313 VDD.t312 pfet_03v3 ad=3.52p pd=16.88u as=2.08p ps=8.52u w=8u l=0.28u
X349 O_SENSE.t2 a_15180_41600.t96 VDD.t5 VDD.t4 pfet_03v3 ad=2.08p pd=8.52u as=2.08p ps=8.52u w=8u l=0.28u
X350 VSS.t287 CLKN_H.t1 a_4812_41600.t2 VSS.t286 nfet_03v3 ad=2.08p pd=8.52u as=2.08p ps=8.52u w=8u l=0.28u
X351 VDD.t291 CLKN_HB.t21 a_2700_41600.t6 VDD.t290 pfet_03v3 ad=2.08p pd=8.52u as=2.08p ps=8.52u w=8u l=0.28u
X352 a_6924_41600.t9 CLKN_HB.t18 VDD.t297 VDD.t296 pfet_03v3 ad=2.08p pd=8.52u as=2.08p ps=8.52u w=8u l=0.28u
X353 a_15180_41600.t47 a_6924_41600.t32 VSS.t337 VSS.t336 nfet_03v3 ad=2.08p pd=8.52u as=2.08p ps=8.52u w=8u l=0.28u
X354 VDD.t259 CLKP_HB.t21 a_2700_6400.t6 VDD.t258 pfet_03v3 ad=2.08p pd=8.52u as=2.08p ps=8.52u w=8u l=0.28u
X355 VSS.t135 a_15180_6400.t69 E_SENSE.t15 VSS.t134 nfet_03v3 ad=2.08p pd=8.52u as=2.08p ps=8.52u w=8u l=0.28u
X356 VSS.t43 a_15180_41600.t59 O_SENSE.t12 VSS.t42 nfet_03v3 ad=2.08p pd=8.52u as=2.08p ps=8.52u w=8u l=0.28u
X357 E_SENSE.t44 a_15180_6400.t106 VDD.t207 VDD.t206 pfet_03v3 ad=2.08p pd=8.52u as=2.08p ps=8.52u w=8u l=0.28u
X358 VSS.t159 a_15180_6400.t67 E_SENSE.t27 VSS.t158 nfet_03v3 ad=2.08p pd=8.52u as=2.08p ps=8.52u w=8u l=0.28u
X359 VSS.t299 CLKN_HB.t5 a_6924_41600.t2 VSS.t298 nfet_03v3 ad=2.08p pd=8.52u as=2.08p ps=8.52u w=8u l=0.28u
X360 VDD.t309 CLKP_H.t7 a_4812_6400.t4 VDD.t308 pfet_03v3 ad=2.08p pd=8.52u as=3.52p ps=16.88u w=8u l=0.28u
X361 VDD.t217 a_15180_41600.t93 O_SENSE.t57 VDD.t216 pfet_03v3 ad=2.08p pd=8.52u as=2.08p ps=8.52u w=8u l=0.28u
X362 VDD.t315 CLKP_H.t5 a_4812_6400.t6 VDD.t314 pfet_03v3 ad=2.08p pd=8.52u as=2.08p ps=8.52u w=8u l=0.28u
X363 VDD.t301 CLKN_HB.t15 a_6924_41600.t12 VDD.t300 pfet_03v3 ad=2.08p pd=8.52u as=2.08p ps=8.52u w=8u l=0.28u
X364 VDD.t29 a_15180_41600.t115 O_SENSE.t7 VDD.t28 pfet_03v3 ad=2.08p pd=8.52u as=2.08p ps=8.52u w=8u l=0.28u
X365 VSS.t251 a_6924_41600.t29 a_15180_41600.t40 VSS.t250 nfet_03v3 ad=2.08p pd=8.52u as=2.08p ps=8.52u w=8u l=0.28u
X366 a_15180_6400.t0 a_6924_6400.t32 VSS.t7 VSS.t6 nfet_03v3 ad=2.08p pd=8.52u as=2.08p ps=8.52u w=8u l=0.28u
X367 a_6924_6400.t3 CLKP_HB.t4 VSS.t271 VSS.t270 nfet_03v3 ad=2.08p pd=8.52u as=2.08p ps=8.52u w=8u l=0.28u
R0 E_SENSE E_SENSE.n70 12.3642
R1 E_SENSE.n70 E_SENSE.n34 6.5392
R2 E_SENSE.n36 E_SENSE.t54 5.7796
R3 E_SENSE.n1 E_SENSE.t52 5.73764
R4 E_SENSE.n69 E_SENSE.t5 5.59012
R5 E_SENSE.n34 E_SENSE.t1 5.54817
R6 E_SENSE.n36 E_SENSE.n35 5.38537
R7 E_SENSE.n38 E_SENSE.n37 5.38537
R8 E_SENSE.n40 E_SENSE.n39 5.38537
R9 E_SENSE.n42 E_SENSE.n41 5.38537
R10 E_SENSE.n44 E_SENSE.n43 5.38537
R11 E_SENSE.n46 E_SENSE.n45 5.38537
R12 E_SENSE.n48 E_SENSE.n47 5.38537
R13 E_SENSE.n50 E_SENSE.n49 5.38537
R14 E_SENSE.n52 E_SENSE.n51 5.38537
R15 E_SENSE.n54 E_SENSE.n53 5.38537
R16 E_SENSE.n56 E_SENSE.n55 5.38537
R17 E_SENSE.n58 E_SENSE.n57 5.38537
R18 E_SENSE.n60 E_SENSE.n59 5.38537
R19 E_SENSE.n62 E_SENSE.n61 5.38537
R20 E_SENSE.n64 E_SENSE.n63 5.38537
R21 E_SENSE.n66 E_SENSE.n65 5.38537
R22 E_SENSE.n68 E_SENSE.n67 5.38537
R23 E_SENSE.n1 E_SENSE.n0 5.32067
R24 E_SENSE.n3 E_SENSE.n2 5.32067
R25 E_SENSE.n5 E_SENSE.n4 5.32067
R26 E_SENSE.n7 E_SENSE.n6 5.32067
R27 E_SENSE.n9 E_SENSE.n8 5.32067
R28 E_SENSE.n11 E_SENSE.n10 5.32067
R29 E_SENSE.n13 E_SENSE.n12 5.32067
R30 E_SENSE.n15 E_SENSE.n14 5.32067
R31 E_SENSE.n17 E_SENSE.n16 5.32067
R32 E_SENSE.n19 E_SENSE.n18 5.32067
R33 E_SENSE.n21 E_SENSE.n20 5.32067
R34 E_SENSE.n23 E_SENSE.n22 5.32067
R35 E_SENSE.n25 E_SENSE.n24 5.32067
R36 E_SENSE.n27 E_SENSE.n26 5.32067
R37 E_SENSE.n29 E_SENSE.n28 5.32067
R38 E_SENSE.n31 E_SENSE.n30 5.32067
R39 E_SENSE.n33 E_SENSE.n32 5.32067
R40 E_SENSE.n70 E_SENSE.n69 4.61063
R41 E_SENSE.n0 E_SENSE.t22 0.228
R42 E_SENSE.n0 E_SENSE.t53 0.228
R43 E_SENSE.n2 E_SENSE.t20 0.228
R44 E_SENSE.n2 E_SENSE.t23 0.228
R45 E_SENSE.n4 E_SENSE.t46 0.228
R46 E_SENSE.n4 E_SENSE.t21 0.228
R47 E_SENSE.n6 E_SENSE.t64 0.228
R48 E_SENSE.n6 E_SENSE.t47 0.228
R49 E_SENSE.n8 E_SENSE.t10 0.228
R50 E_SENSE.n8 E_SENSE.t65 0.228
R51 E_SENSE.n10 E_SENSE.t38 0.228
R52 E_SENSE.n10 E_SENSE.t11 0.228
R53 E_SENSE.n12 E_SENSE.t2 0.228
R54 E_SENSE.n12 E_SENSE.t39 0.228
R55 E_SENSE.n14 E_SENSE.t30 0.228
R56 E_SENSE.n14 E_SENSE.t3 0.228
R57 E_SENSE.n16 E_SENSE.t56 0.228
R58 E_SENSE.n16 E_SENSE.t31 0.228
R59 E_SENSE.n18 E_SENSE.t16 0.228
R60 E_SENSE.n18 E_SENSE.t57 0.228
R61 E_SENSE.n20 E_SENSE.t44 0.228
R62 E_SENSE.n20 E_SENSE.t17 0.228
R63 E_SENSE.n22 E_SENSE.t62 0.228
R64 E_SENSE.n22 E_SENSE.t45 0.228
R65 E_SENSE.n24 E_SENSE.t36 0.228
R66 E_SENSE.n24 E_SENSE.t63 0.228
R67 E_SENSE.n26 E_SENSE.t28 0.228
R68 E_SENSE.n26 E_SENSE.t37 0.228
R69 E_SENSE.n28 E_SENSE.t60 0.228
R70 E_SENSE.n28 E_SENSE.t29 0.228
R71 E_SENSE.n30 E_SENSE.t8 0.228
R72 E_SENSE.n30 E_SENSE.t61 0.228
R73 E_SENSE.n32 E_SENSE.t0 0.228
R74 E_SENSE.n32 E_SENSE.t9 0.228
R75 E_SENSE.n35 E_SENSE.t50 0.20525
R76 E_SENSE.n35 E_SENSE.t55 0.20525
R77 E_SENSE.n37 E_SENSE.t70 0.20525
R78 E_SENSE.n37 E_SENSE.t51 0.20525
R79 E_SENSE.n39 E_SENSE.t42 0.20525
R80 E_SENSE.n39 E_SENSE.t71 0.20525
R81 E_SENSE.n41 E_SENSE.t34 0.20525
R82 E_SENSE.n41 E_SENSE.t43 0.20525
R83 E_SENSE.n43 E_SENSE.t58 0.20525
R84 E_SENSE.n43 E_SENSE.t35 0.20525
R85 E_SENSE.n45 E_SENSE.t18 0.20525
R86 E_SENSE.n45 E_SENSE.t59 0.20525
R87 E_SENSE.n47 E_SENSE.t48 0.20525
R88 E_SENSE.n47 E_SENSE.t19 0.20525
R89 E_SENSE.n49 E_SENSE.t68 0.20525
R90 E_SENSE.n49 E_SENSE.t49 0.20525
R91 E_SENSE.n51 E_SENSE.t26 0.20525
R92 E_SENSE.n51 E_SENSE.t69 0.20525
R93 E_SENSE.n53 E_SENSE.t14 0.20525
R94 E_SENSE.n53 E_SENSE.t27 0.20525
R95 E_SENSE.n55 E_SENSE.t6 0.20525
R96 E_SENSE.n55 E_SENSE.t15 0.20525
R97 E_SENSE.n57 E_SENSE.t40 0.20525
R98 E_SENSE.n57 E_SENSE.t7 0.20525
R99 E_SENSE.n59 E_SENSE.t32 0.20525
R100 E_SENSE.n59 E_SENSE.t41 0.20525
R101 E_SENSE.n61 E_SENSE.t66 0.20525
R102 E_SENSE.n61 E_SENSE.t33 0.20525
R103 E_SENSE.n63 E_SENSE.t24 0.20525
R104 E_SENSE.n63 E_SENSE.t67 0.20525
R105 E_SENSE.n65 E_SENSE.t12 0.20525
R106 E_SENSE.n65 E_SENSE.t25 0.20525
R107 E_SENSE.n67 E_SENSE.t4 0.20525
R108 E_SENSE.n67 E_SENSE.t13 0.20525
R109 E_SENSE.n69 E_SENSE.n68 0.189974
R110 E_SENSE.n68 E_SENSE.n66 0.189974
R111 E_SENSE.n66 E_SENSE.n64 0.189974
R112 E_SENSE.n64 E_SENSE.n62 0.189974
R113 E_SENSE.n62 E_SENSE.n60 0.189974
R114 E_SENSE.n60 E_SENSE.n58 0.189974
R115 E_SENSE.n58 E_SENSE.n56 0.189974
R116 E_SENSE.n56 E_SENSE.n54 0.189974
R117 E_SENSE.n54 E_SENSE.n52 0.189974
R118 E_SENSE.n52 E_SENSE.n50 0.189974
R119 E_SENSE.n50 E_SENSE.n48 0.189974
R120 E_SENSE.n48 E_SENSE.n46 0.189974
R121 E_SENSE.n46 E_SENSE.n44 0.189974
R122 E_SENSE.n44 E_SENSE.n42 0.189974
R123 E_SENSE.n42 E_SENSE.n40 0.189974
R124 E_SENSE.n40 E_SENSE.n38 0.189974
R125 E_SENSE.n38 E_SENSE.n36 0.189974
R126 E_SENSE.n34 E_SENSE.n33 0.189974
R127 E_SENSE.n33 E_SENSE.n31 0.189974
R128 E_SENSE.n31 E_SENSE.n29 0.189974
R129 E_SENSE.n29 E_SENSE.n27 0.189974
R130 E_SENSE.n27 E_SENSE.n25 0.189974
R131 E_SENSE.n25 E_SENSE.n23 0.189974
R132 E_SENSE.n23 E_SENSE.n21 0.189974
R133 E_SENSE.n21 E_SENSE.n19 0.189974
R134 E_SENSE.n19 E_SENSE.n17 0.189974
R135 E_SENSE.n17 E_SENSE.n15 0.189974
R136 E_SENSE.n15 E_SENSE.n13 0.189974
R137 E_SENSE.n13 E_SENSE.n11 0.189974
R138 E_SENSE.n11 E_SENSE.n9 0.189974
R139 E_SENSE.n9 E_SENSE.n7 0.189974
R140 E_SENSE.n7 E_SENSE.n5 0.189974
R141 E_SENSE.n5 E_SENSE.n3 0.189974
R142 E_SENSE.n3 E_SENSE.n1 0.189974
R143 E_CAPTURE_CLK E_CAPTURE_CLK.n14 7.98157
R144 E_CAPTURE_CLK.n14 E_CAPTURE_CLK.n6 6.5392
R145 E_CAPTURE_CLK.n8 E_CAPTURE_CLK.t14 5.7796
R146 E_CAPTURE_CLK.n1 E_CAPTURE_CLK.t13 5.73764
R147 E_CAPTURE_CLK.n13 E_CAPTURE_CLK.t4 5.59012
R148 E_CAPTURE_CLK.n6 E_CAPTURE_CLK.t1 5.54817
R149 E_CAPTURE_CLK.n8 E_CAPTURE_CLK.n7 5.38537
R150 E_CAPTURE_CLK.n10 E_CAPTURE_CLK.n9 5.38537
R151 E_CAPTURE_CLK.n12 E_CAPTURE_CLK.n11 5.38537
R152 E_CAPTURE_CLK.n1 E_CAPTURE_CLK.n0 5.32067
R153 E_CAPTURE_CLK.n3 E_CAPTURE_CLK.n2 5.32067
R154 E_CAPTURE_CLK.n5 E_CAPTURE_CLK.n4 5.32067
R155 E_CAPTURE_CLK.n14 E_CAPTURE_CLK.n13 4.61063
R156 E_CAPTURE_CLK.n0 E_CAPTURE_CLK.t6 0.228
R157 E_CAPTURE_CLK.n0 E_CAPTURE_CLK.t11 0.228
R158 E_CAPTURE_CLK.n2 E_CAPTURE_CLK.t2 0.228
R159 E_CAPTURE_CLK.n2 E_CAPTURE_CLK.t3 0.228
R160 E_CAPTURE_CLK.n4 E_CAPTURE_CLK.t0 0.228
R161 E_CAPTURE_CLK.n4 E_CAPTURE_CLK.t15 0.228
R162 E_CAPTURE_CLK.n7 E_CAPTURE_CLK.t12 0.20525
R163 E_CAPTURE_CLK.n7 E_CAPTURE_CLK.t8 0.20525
R164 E_CAPTURE_CLK.n9 E_CAPTURE_CLK.t9 0.20525
R165 E_CAPTURE_CLK.n9 E_CAPTURE_CLK.t10 0.20525
R166 E_CAPTURE_CLK.n11 E_CAPTURE_CLK.t7 0.20525
R167 E_CAPTURE_CLK.n11 E_CAPTURE_CLK.t5 0.20525
R168 E_CAPTURE_CLK.n13 E_CAPTURE_CLK.n12 0.189974
R169 E_CAPTURE_CLK.n12 E_CAPTURE_CLK.n10 0.189974
R170 E_CAPTURE_CLK.n10 E_CAPTURE_CLK.n8 0.189974
R171 E_CAPTURE_CLK.n6 E_CAPTURE_CLK.n5 0.189974
R172 E_CAPTURE_CLK.n5 E_CAPTURE_CLK.n3 0.189974
R173 E_CAPTURE_CLK.n3 E_CAPTURE_CLK.n1 0.189974
R174 E_CAPTURE_CLKB E_CAPTURE_CLKB.n14 6.63157
R175 E_CAPTURE_CLKB.n14 E_CAPTURE_CLKB.n6 6.5392
R176 E_CAPTURE_CLKB.n8 E_CAPTURE_CLKB.t0 5.7796
R177 E_CAPTURE_CLKB.n1 E_CAPTURE_CLKB.t8 5.73764
R178 E_CAPTURE_CLKB.n13 E_CAPTURE_CLKB.t14 5.59012
R179 E_CAPTURE_CLKB.n6 E_CAPTURE_CLKB.t13 5.54817
R180 E_CAPTURE_CLKB.n8 E_CAPTURE_CLKB.n7 5.38537
R181 E_CAPTURE_CLKB.n10 E_CAPTURE_CLKB.n9 5.38537
R182 E_CAPTURE_CLKB.n12 E_CAPTURE_CLKB.n11 5.38537
R183 E_CAPTURE_CLKB.n1 E_CAPTURE_CLKB.n0 5.32067
R184 E_CAPTURE_CLKB.n3 E_CAPTURE_CLKB.n2 5.32067
R185 E_CAPTURE_CLKB.n5 E_CAPTURE_CLKB.n4 5.32067
R186 E_CAPTURE_CLKB.n14 E_CAPTURE_CLKB.n13 4.61063
R187 E_CAPTURE_CLKB.n0 E_CAPTURE_CLKB.t9 0.228
R188 E_CAPTURE_CLKB.n0 E_CAPTURE_CLKB.t10 0.228
R189 E_CAPTURE_CLKB.n2 E_CAPTURE_CLKB.t15 0.228
R190 E_CAPTURE_CLKB.n2 E_CAPTURE_CLKB.t1 0.228
R191 E_CAPTURE_CLKB.n4 E_CAPTURE_CLKB.t12 0.228
R192 E_CAPTURE_CLKB.n4 E_CAPTURE_CLKB.t11 0.228
R193 E_CAPTURE_CLKB.n7 E_CAPTURE_CLKB.t4 0.20525
R194 E_CAPTURE_CLKB.n7 E_CAPTURE_CLKB.t6 0.20525
R195 E_CAPTURE_CLKB.n9 E_CAPTURE_CLKB.t7 0.20525
R196 E_CAPTURE_CLKB.n9 E_CAPTURE_CLKB.t3 0.20525
R197 E_CAPTURE_CLKB.n11 E_CAPTURE_CLKB.t2 0.20525
R198 E_CAPTURE_CLKB.n11 E_CAPTURE_CLKB.t5 0.20525
R199 E_CAPTURE_CLKB.n13 E_CAPTURE_CLKB.n12 0.189974
R200 E_CAPTURE_CLKB.n12 E_CAPTURE_CLKB.n10 0.189974
R201 E_CAPTURE_CLKB.n10 E_CAPTURE_CLKB.n8 0.189974
R202 E_CAPTURE_CLKB.n6 E_CAPTURE_CLKB.n5 0.189974
R203 E_CAPTURE_CLKB.n5 E_CAPTURE_CLKB.n3 0.189974
R204 E_CAPTURE_CLKB.n3 E_CAPTURE_CLKB.n1 0.189974
R205 CLKP_H.n8 CLKP_H.t3 113.632
R206 CLKP_H.n5 CLKP_H.t0 113.632
R207 CLKP_H.n0 CLKP_H.t4 113.632
R208 CLKP_H.n3 CLKP_H.t7 113.632
R209 CLKP_H.n6 CLKP_H.t1 109.174
R210 CLKP_H.n7 CLKP_H.t2 109.174
R211 CLKP_H.n1 CLKP_H.t5 109.174
R212 CLKP_H.n2 CLKP_H.t6 109.174
R213 CLKP_H CLKP_H.n10 15.3874
R214 CLKP_H.n7 CLKP_H.n6 11.6805
R215 CLKP_H.n2 CLKP_H.n1 11.6805
R216 CLKP_H.n10 CLKP_H.n4 10.9291
R217 CLKP_H.n10 CLKP_H.n9 9.0005
R218 CLKP_H.n9 CLKP_H.n5 7.10487
R219 CLKP_H.n9 CLKP_H.n8 7.10487
R220 CLKP_H.n4 CLKP_H.n0 7.10487
R221 CLKP_H.n4 CLKP_H.n3 7.10487
R222 CLKP_H.n6 CLKP_H.n5 4.42851
R223 CLKP_H.n8 CLKP_H.n7 4.42851
R224 CLKP_H.n1 CLKP_H.n0 4.42851
R225 CLKP_H.n3 CLKP_H.n2 4.42851
R226 CLKP_HB.n15 CLKP_HB.t7 113.632
R227 CLKP_HB.n19 CLKP_HB.t0 113.632
R228 CLKP_HB.n2 CLKP_HB.t19 113.632
R229 CLKP_HB.n6 CLKP_HB.t12 113.632
R230 CLKP_HB.n35 CLKP_HB.t11 113.632
R231 CLKP_HB.n32 CLKP_HB.t8 113.632
R232 CLKP_HB.n27 CLKP_HB.t20 113.632
R233 CLKP_HB.n30 CLKP_HB.t23 113.632
R234 CLKP_HB.n22 CLKP_HB.t3 109.174
R235 CLKP_HB.n23 CLKP_HB.t4 109.174
R236 CLKP_HB.n16 CLKP_HB.t6 109.174
R237 CLKP_HB.n17 CLKP_HB.t5 109.174
R238 CLKP_HB.n21 CLKP_HB.t2 109.174
R239 CLKP_HB.n18 CLKP_HB.t1 109.174
R240 CLKP_HB.n9 CLKP_HB.t15 109.174
R241 CLKP_HB.n10 CLKP_HB.t16 109.174
R242 CLKP_HB.n3 CLKP_HB.t18 109.174
R243 CLKP_HB.n4 CLKP_HB.t17 109.174
R244 CLKP_HB.n8 CLKP_HB.t14 109.174
R245 CLKP_HB.n5 CLKP_HB.t13 109.174
R246 CLKP_HB.n33 CLKP_HB.t9 109.174
R247 CLKP_HB.n34 CLKP_HB.t10 109.174
R248 CLKP_HB.n28 CLKP_HB.t21 109.174
R249 CLKP_HB.n29 CLKP_HB.t22 109.174
R250 CLKP_HB.n22 CLKP_HB.n13 18.4942
R251 CLKP_HB.n24 CLKP_HB.n23 18.4942
R252 CLKP_HB.n17 CLKP_HB.n14 18.4942
R253 CLKP_HB.n21 CLKP_HB.n20 18.4942
R254 CLKP_HB.n9 CLKP_HB.n0 18.4942
R255 CLKP_HB.n11 CLKP_HB.n10 18.4942
R256 CLKP_HB.n4 CLKP_HB.n1 18.4942
R257 CLKP_HB.n8 CLKP_HB.n7 18.4942
R258 CLKP_HB.n22 CLKP_HB.n21 11.6805
R259 CLKP_HB.n23 CLKP_HB.n22 11.6805
R260 CLKP_HB.n17 CLKP_HB.n16 11.6805
R261 CLKP_HB.n23 CLKP_HB.n17 11.6805
R262 CLKP_HB.n21 CLKP_HB.n18 11.6805
R263 CLKP_HB.n9 CLKP_HB.n8 11.6805
R264 CLKP_HB.n10 CLKP_HB.n9 11.6805
R265 CLKP_HB.n4 CLKP_HB.n3 11.6805
R266 CLKP_HB.n10 CLKP_HB.n4 11.6805
R267 CLKP_HB.n8 CLKP_HB.n5 11.6805
R268 CLKP_HB.n34 CLKP_HB.n33 11.6805
R269 CLKP_HB.n29 CLKP_HB.n28 11.6805
R270 CLKP_HB.n26 CLKP_HB.n12 10.9291
R271 CLKP_HB.n37 CLKP_HB.n31 10.9291
R272 CLKP_HB.n38 CLKP_HB.n26 9.02258
R273 CLKP_HB.n26 CLKP_HB.n25 9.0005
R274 CLKP_HB.n37 CLKP_HB.n36 9.0005
R275 CLKP_HB CLKP_HB.n38 8.25354
R276 CLKP_HB.n20 CLKP_HB.n19 7.17687
R277 CLKP_HB.n15 CLKP_HB.n14 7.17687
R278 CLKP_HB.n7 CLKP_HB.n6 7.17687
R279 CLKP_HB.n2 CLKP_HB.n1 7.17687
R280 CLKP_HB.n36 CLKP_HB.n32 7.10487
R281 CLKP_HB.n36 CLKP_HB.n35 7.10487
R282 CLKP_HB.n31 CLKP_HB.n27 7.10487
R283 CLKP_HB.n31 CLKP_HB.n30 7.10487
R284 CLKP_HB.n38 CLKP_HB.n37 4.59693
R285 CLKP_HB.n16 CLKP_HB.n15 4.42851
R286 CLKP_HB.n19 CLKP_HB.n18 4.42851
R287 CLKP_HB.n3 CLKP_HB.n2 4.42851
R288 CLKP_HB.n6 CLKP_HB.n5 4.42851
R289 CLKP_HB.n33 CLKP_HB.n32 4.42851
R290 CLKP_HB.n35 CLKP_HB.n34 4.42851
R291 CLKP_HB.n28 CLKP_HB.n27 4.42851
R292 CLKP_HB.n30 CLKP_HB.n29 4.42851
R293 CLKP_HB.n20 CLKP_HB.n13 0.1205
R294 CLKP_HB.n24 CLKP_HB.n14 0.1205
R295 CLKP_HB.n7 CLKP_HB.n0 0.1205
R296 CLKP_HB.n11 CLKP_HB.n1 0.1205
R297 CLKP_HB.n25 CLKP_HB.n13 0.0485
R298 CLKP_HB.n25 CLKP_HB.n24 0.0485
R299 CLKP_HB.n12 CLKP_HB.n0 0.0485
R300 CLKP_HB.n12 CLKP_HB.n11 0.0485
R301 O_SENSE O_SENSE.n70 12.3642
R302 O_SENSE.n70 O_SENSE.n34 6.5392
R303 O_SENSE.n36 O_SENSE.t43 5.7796
R304 O_SENSE.n1 O_SENSE.t50 5.73764
R305 O_SENSE.n69 O_SENSE.t34 5.59012
R306 O_SENSE.n34 O_SENSE.t0 5.54817
R307 O_SENSE.n36 O_SENSE.n35 5.38537
R308 O_SENSE.n38 O_SENSE.n37 5.38537
R309 O_SENSE.n40 O_SENSE.n39 5.38537
R310 O_SENSE.n42 O_SENSE.n41 5.38537
R311 O_SENSE.n44 O_SENSE.n43 5.38537
R312 O_SENSE.n46 O_SENSE.n45 5.38537
R313 O_SENSE.n48 O_SENSE.n47 5.38537
R314 O_SENSE.n50 O_SENSE.n49 5.38537
R315 O_SENSE.n52 O_SENSE.n51 5.38537
R316 O_SENSE.n54 O_SENSE.n53 5.38537
R317 O_SENSE.n56 O_SENSE.n55 5.38537
R318 O_SENSE.n58 O_SENSE.n57 5.38537
R319 O_SENSE.n60 O_SENSE.n59 5.38537
R320 O_SENSE.n62 O_SENSE.n61 5.38537
R321 O_SENSE.n64 O_SENSE.n63 5.38537
R322 O_SENSE.n66 O_SENSE.n65 5.38537
R323 O_SENSE.n68 O_SENSE.n67 5.38537
R324 O_SENSE.n1 O_SENSE.n0 5.32067
R325 O_SENSE.n3 O_SENSE.n2 5.32067
R326 O_SENSE.n5 O_SENSE.n4 5.32067
R327 O_SENSE.n7 O_SENSE.n6 5.32067
R328 O_SENSE.n9 O_SENSE.n8 5.32067
R329 O_SENSE.n11 O_SENSE.n10 5.32067
R330 O_SENSE.n13 O_SENSE.n12 5.32067
R331 O_SENSE.n15 O_SENSE.n14 5.32067
R332 O_SENSE.n17 O_SENSE.n16 5.32067
R333 O_SENSE.n19 O_SENSE.n18 5.32067
R334 O_SENSE.n21 O_SENSE.n20 5.32067
R335 O_SENSE.n23 O_SENSE.n22 5.32067
R336 O_SENSE.n25 O_SENSE.n24 5.32067
R337 O_SENSE.n27 O_SENSE.n26 5.32067
R338 O_SENSE.n29 O_SENSE.n28 5.32067
R339 O_SENSE.n31 O_SENSE.n30 5.32067
R340 O_SENSE.n33 O_SENSE.n32 5.32067
R341 O_SENSE.n70 O_SENSE.n69 4.61063
R342 O_SENSE.n0 O_SENSE.t66 0.228
R343 O_SENSE.n0 O_SENSE.t46 0.228
R344 O_SENSE.n2 O_SENSE.t42 0.228
R345 O_SENSE.n2 O_SENSE.t44 0.228
R346 O_SENSE.n4 O_SENSE.t9 0.228
R347 O_SENSE.n4 O_SENSE.t24 0.228
R348 O_SENSE.n6 O_SENSE.t16 0.228
R349 O_SENSE.n6 O_SENSE.t3 0.228
R350 O_SENSE.n8 O_SENSE.t23 0.228
R351 O_SENSE.n8 O_SENSE.t57 0.228
R352 O_SENSE.n10 O_SENSE.t2 0.228
R353 O_SENSE.n10 O_SENSE.t8 0.228
R354 O_SENSE.n12 O_SENSE.t56 0.228
R355 O_SENSE.n12 O_SENSE.t15 0.228
R356 O_SENSE.n14 O_SENSE.t33 0.228
R357 O_SENSE.n14 O_SENSE.t60 0.228
R358 O_SENSE.n16 O_SENSE.t32 0.228
R359 O_SENSE.n16 O_SENSE.t65 0.228
R360 O_SENSE.n18 O_SENSE.t1 0.228
R361 O_SENSE.n18 O_SENSE.t22 0.228
R362 O_SENSE.n20 O_SENSE.t53 0.228
R363 O_SENSE.n20 O_SENSE.t62 0.228
R364 O_SENSE.n22 O_SENSE.t31 0.228
R365 O_SENSE.n22 O_SENSE.t40 0.228
R366 O_SENSE.n24 O_SENSE.t45 0.228
R367 O_SENSE.n24 O_SENSE.t49 0.228
R368 O_SENSE.n26 O_SENSE.t52 0.228
R369 O_SENSE.n26 O_SENSE.t64 0.228
R370 O_SENSE.n28 O_SENSE.t30 0.228
R371 O_SENSE.n28 O_SENSE.t38 0.228
R372 O_SENSE.n30 O_SENSE.t20 0.228
R373 O_SENSE.n30 O_SENSE.t7 0.228
R374 O_SENSE.n32 O_SENSE.t48 0.228
R375 O_SENSE.n32 O_SENSE.t21 0.228
R376 O_SENSE.n35 O_SENSE.t14 0.20525
R377 O_SENSE.n35 O_SENSE.t29 0.20525
R378 O_SENSE.n37 O_SENSE.t19 0.20525
R379 O_SENSE.n37 O_SENSE.t6 0.20525
R380 O_SENSE.n39 O_SENSE.t28 0.20525
R381 O_SENSE.n39 O_SENSE.t59 0.20525
R382 O_SENSE.n41 O_SENSE.t5 0.20525
R383 O_SENSE.n41 O_SENSE.t13 0.20525
R384 O_SENSE.n43 O_SENSE.t27 0.20525
R385 O_SENSE.n43 O_SENSE.t18 0.20525
R386 O_SENSE.n45 O_SENSE.t58 0.20525
R387 O_SENSE.n45 O_SENSE.t12 0.20525
R388 O_SENSE.n47 O_SENSE.t37 0.20525
R389 O_SENSE.n47 O_SENSE.t61 0.20525
R390 O_SENSE.n49 O_SENSE.t71 0.20525
R391 O_SENSE.n49 O_SENSE.t68 0.20525
R392 O_SENSE.n51 O_SENSE.t26 0.20525
R393 O_SENSE.n51 O_SENSE.t36 0.20525
R394 O_SENSE.n53 O_SENSE.t63 0.20525
R395 O_SENSE.n53 O_SENSE.t11 0.20525
R396 O_SENSE.n55 O_SENSE.t70 0.20525
R397 O_SENSE.n55 O_SENSE.t55 0.20525
R398 O_SENSE.n57 O_SENSE.t35 0.20525
R399 O_SENSE.n57 O_SENSE.t41 0.20525
R400 O_SENSE.n59 O_SENSE.t10 0.20525
R401 O_SENSE.n59 O_SENSE.t25 0.20525
R402 O_SENSE.n61 O_SENSE.t4 0.20525
R403 O_SENSE.n61 O_SENSE.t51 0.20525
R404 O_SENSE.n63 O_SENSE.t47 0.20525
R405 O_SENSE.n63 O_SENSE.t17 0.20525
R406 O_SENSE.n65 O_SENSE.t54 0.20525
R407 O_SENSE.n65 O_SENSE.t67 0.20525
R408 O_SENSE.n67 O_SENSE.t39 0.20525
R409 O_SENSE.n67 O_SENSE.t69 0.20525
R410 O_SENSE.n69 O_SENSE.n68 0.189974
R411 O_SENSE.n68 O_SENSE.n66 0.189974
R412 O_SENSE.n66 O_SENSE.n64 0.189974
R413 O_SENSE.n64 O_SENSE.n62 0.189974
R414 O_SENSE.n62 O_SENSE.n60 0.189974
R415 O_SENSE.n60 O_SENSE.n58 0.189974
R416 O_SENSE.n58 O_SENSE.n56 0.189974
R417 O_SENSE.n56 O_SENSE.n54 0.189974
R418 O_SENSE.n54 O_SENSE.n52 0.189974
R419 O_SENSE.n52 O_SENSE.n50 0.189974
R420 O_SENSE.n50 O_SENSE.n48 0.189974
R421 O_SENSE.n48 O_SENSE.n46 0.189974
R422 O_SENSE.n46 O_SENSE.n44 0.189974
R423 O_SENSE.n44 O_SENSE.n42 0.189974
R424 O_SENSE.n42 O_SENSE.n40 0.189974
R425 O_SENSE.n40 O_SENSE.n38 0.189974
R426 O_SENSE.n38 O_SENSE.n36 0.189974
R427 O_SENSE.n34 O_SENSE.n33 0.189974
R428 O_SENSE.n33 O_SENSE.n31 0.189974
R429 O_SENSE.n31 O_SENSE.n29 0.189974
R430 O_SENSE.n29 O_SENSE.n27 0.189974
R431 O_SENSE.n27 O_SENSE.n25 0.189974
R432 O_SENSE.n25 O_SENSE.n23 0.189974
R433 O_SENSE.n23 O_SENSE.n21 0.189974
R434 O_SENSE.n21 O_SENSE.n19 0.189974
R435 O_SENSE.n19 O_SENSE.n17 0.189974
R436 O_SENSE.n17 O_SENSE.n15 0.189974
R437 O_SENSE.n15 O_SENSE.n13 0.189974
R438 O_SENSE.n13 O_SENSE.n11 0.189974
R439 O_SENSE.n11 O_SENSE.n9 0.189974
R440 O_SENSE.n9 O_SENSE.n7 0.189974
R441 O_SENSE.n7 O_SENSE.n5 0.189974
R442 O_SENSE.n5 O_SENSE.n3 0.189974
R443 O_SENSE.n3 O_SENSE.n1 0.189974
R444 O_CAPTURE_CLK O_CAPTURE_CLK.n14 7.98157
R445 O_CAPTURE_CLK.n14 O_CAPTURE_CLK.n6 6.5392
R446 O_CAPTURE_CLK.n8 O_CAPTURE_CLK.t0 5.7796
R447 O_CAPTURE_CLK.n1 O_CAPTURE_CLK.t10 5.73764
R448 O_CAPTURE_CLK.n13 O_CAPTURE_CLK.t9 5.59012
R449 O_CAPTURE_CLK.n6 O_CAPTURE_CLK.t15 5.54817
R450 O_CAPTURE_CLK.n8 O_CAPTURE_CLK.n7 5.38537
R451 O_CAPTURE_CLK.n10 O_CAPTURE_CLK.n9 5.38537
R452 O_CAPTURE_CLK.n12 O_CAPTURE_CLK.n11 5.38537
R453 O_CAPTURE_CLK.n1 O_CAPTURE_CLK.n0 5.32067
R454 O_CAPTURE_CLK.n3 O_CAPTURE_CLK.n2 5.32067
R455 O_CAPTURE_CLK.n5 O_CAPTURE_CLK.n4 5.32067
R456 O_CAPTURE_CLK.n14 O_CAPTURE_CLK.n13 4.61063
R457 O_CAPTURE_CLK.n0 O_CAPTURE_CLK.t8 0.228
R458 O_CAPTURE_CLK.n0 O_CAPTURE_CLK.t7 0.228
R459 O_CAPTURE_CLK.n2 O_CAPTURE_CLK.t14 0.228
R460 O_CAPTURE_CLK.n2 O_CAPTURE_CLK.t13 0.228
R461 O_CAPTURE_CLK.n4 O_CAPTURE_CLK.t2 0.228
R462 O_CAPTURE_CLK.n4 O_CAPTURE_CLK.t1 0.228
R463 O_CAPTURE_CLK.n7 O_CAPTURE_CLK.t6 0.20525
R464 O_CAPTURE_CLK.n7 O_CAPTURE_CLK.t5 0.20525
R465 O_CAPTURE_CLK.n9 O_CAPTURE_CLK.t4 0.20525
R466 O_CAPTURE_CLK.n9 O_CAPTURE_CLK.t3 0.20525
R467 O_CAPTURE_CLK.n11 O_CAPTURE_CLK.t12 0.20525
R468 O_CAPTURE_CLK.n11 O_CAPTURE_CLK.t11 0.20525
R469 O_CAPTURE_CLK.n13 O_CAPTURE_CLK.n12 0.189974
R470 O_CAPTURE_CLK.n12 O_CAPTURE_CLK.n10 0.189974
R471 O_CAPTURE_CLK.n10 O_CAPTURE_CLK.n8 0.189974
R472 O_CAPTURE_CLK.n6 O_CAPTURE_CLK.n5 0.189974
R473 O_CAPTURE_CLK.n5 O_CAPTURE_CLK.n3 0.189974
R474 O_CAPTURE_CLK.n3 O_CAPTURE_CLK.n1 0.189974
R475 O_CAPTURE_CLKB O_CAPTURE_CLKB.n14 6.63157
R476 O_CAPTURE_CLKB.n14 O_CAPTURE_CLKB.n6 6.5392
R477 O_CAPTURE_CLKB.n8 O_CAPTURE_CLKB.t11 5.7796
R478 O_CAPTURE_CLKB.n1 O_CAPTURE_CLKB.t13 5.73764
R479 O_CAPTURE_CLKB.n13 O_CAPTURE_CLKB.t12 5.59012
R480 O_CAPTURE_CLKB.n6 O_CAPTURE_CLKB.t7 5.54817
R481 O_CAPTURE_CLKB.n8 O_CAPTURE_CLKB.n7 5.38537
R482 O_CAPTURE_CLKB.n10 O_CAPTURE_CLKB.n9 5.38537
R483 O_CAPTURE_CLKB.n12 O_CAPTURE_CLKB.n11 5.38537
R484 O_CAPTURE_CLKB.n1 O_CAPTURE_CLKB.n0 5.32067
R485 O_CAPTURE_CLKB.n3 O_CAPTURE_CLKB.n2 5.32067
R486 O_CAPTURE_CLKB.n5 O_CAPTURE_CLKB.n4 5.32067
R487 O_CAPTURE_CLKB.n14 O_CAPTURE_CLKB.n13 4.61063
R488 O_CAPTURE_CLKB.n0 O_CAPTURE_CLKB.t9 0.228
R489 O_CAPTURE_CLKB.n0 O_CAPTURE_CLKB.t8 0.228
R490 O_CAPTURE_CLKB.n2 O_CAPTURE_CLKB.t15 0.228
R491 O_CAPTURE_CLKB.n2 O_CAPTURE_CLKB.t14 0.228
R492 O_CAPTURE_CLKB.n4 O_CAPTURE_CLKB.t5 0.228
R493 O_CAPTURE_CLKB.n4 O_CAPTURE_CLKB.t4 0.228
R494 O_CAPTURE_CLKB.n7 O_CAPTURE_CLKB.t3 0.20525
R495 O_CAPTURE_CLKB.n7 O_CAPTURE_CLKB.t10 0.20525
R496 O_CAPTURE_CLKB.n9 O_CAPTURE_CLKB.t2 0.20525
R497 O_CAPTURE_CLKB.n9 O_CAPTURE_CLKB.t6 0.20525
R498 O_CAPTURE_CLKB.n11 O_CAPTURE_CLKB.t1 0.20525
R499 O_CAPTURE_CLKB.n11 O_CAPTURE_CLKB.t0 0.20525
R500 O_CAPTURE_CLKB.n13 O_CAPTURE_CLKB.n12 0.189974
R501 O_CAPTURE_CLKB.n12 O_CAPTURE_CLKB.n10 0.189974
R502 O_CAPTURE_CLKB.n10 O_CAPTURE_CLKB.n8 0.189974
R503 O_CAPTURE_CLKB.n6 O_CAPTURE_CLKB.n5 0.189974
R504 O_CAPTURE_CLKB.n5 O_CAPTURE_CLKB.n3 0.189974
R505 O_CAPTURE_CLKB.n3 O_CAPTURE_CLKB.n1 0.189974
R506 CLKN_H.n8 CLKN_H.t3 113.632
R507 CLKN_H.n5 CLKN_H.t0 113.632
R508 CLKN_H.n0 CLKN_H.t4 113.632
R509 CLKN_H.n3 CLKN_H.t7 113.632
R510 CLKN_H.n6 CLKN_H.t1 109.174
R511 CLKN_H.n7 CLKN_H.t2 109.174
R512 CLKN_H.n1 CLKN_H.t5 109.174
R513 CLKN_H.n2 CLKN_H.t6 109.174
R514 CLKN_H CLKN_H.n10 15.3874
R515 CLKN_H.n7 CLKN_H.n6 11.6805
R516 CLKN_H.n2 CLKN_H.n1 11.6805
R517 CLKN_H.n10 CLKN_H.n4 10.9291
R518 CLKN_H.n10 CLKN_H.n9 9.0005
R519 CLKN_H.n9 CLKN_H.n5 7.10487
R520 CLKN_H.n9 CLKN_H.n8 7.10487
R521 CLKN_H.n4 CLKN_H.n0 7.10487
R522 CLKN_H.n4 CLKN_H.n3 7.10487
R523 CLKN_H.n6 CLKN_H.n5 4.42851
R524 CLKN_H.n8 CLKN_H.n7 4.42851
R525 CLKN_H.n1 CLKN_H.n0 4.42851
R526 CLKN_H.n3 CLKN_H.n2 4.42851
R527 CLKN_HB.n15 CLKN_HB.t7 113.632
R528 CLKN_HB.n19 CLKN_HB.t0 113.632
R529 CLKN_HB.n2 CLKN_HB.t19 113.632
R530 CLKN_HB.n6 CLKN_HB.t12 113.632
R531 CLKN_HB.n35 CLKN_HB.t11 113.632
R532 CLKN_HB.n32 CLKN_HB.t8 113.632
R533 CLKN_HB.n27 CLKN_HB.t20 113.632
R534 CLKN_HB.n30 CLKN_HB.t23 113.632
R535 CLKN_HB.n22 CLKN_HB.t3 109.174
R536 CLKN_HB.n23 CLKN_HB.t4 109.174
R537 CLKN_HB.n16 CLKN_HB.t6 109.174
R538 CLKN_HB.n17 CLKN_HB.t5 109.174
R539 CLKN_HB.n21 CLKN_HB.t2 109.174
R540 CLKN_HB.n18 CLKN_HB.t1 109.174
R541 CLKN_HB.n9 CLKN_HB.t15 109.174
R542 CLKN_HB.n10 CLKN_HB.t16 109.174
R543 CLKN_HB.n3 CLKN_HB.t18 109.174
R544 CLKN_HB.n4 CLKN_HB.t17 109.174
R545 CLKN_HB.n8 CLKN_HB.t14 109.174
R546 CLKN_HB.n5 CLKN_HB.t13 109.174
R547 CLKN_HB.n33 CLKN_HB.t9 109.174
R548 CLKN_HB.n34 CLKN_HB.t10 109.174
R549 CLKN_HB.n28 CLKN_HB.t21 109.174
R550 CLKN_HB.n29 CLKN_HB.t22 109.174
R551 CLKN_HB.n22 CLKN_HB.n13 18.4942
R552 CLKN_HB.n24 CLKN_HB.n23 18.4942
R553 CLKN_HB.n17 CLKN_HB.n14 18.4942
R554 CLKN_HB.n21 CLKN_HB.n20 18.4942
R555 CLKN_HB.n9 CLKN_HB.n0 18.4942
R556 CLKN_HB.n11 CLKN_HB.n10 18.4942
R557 CLKN_HB.n4 CLKN_HB.n1 18.4942
R558 CLKN_HB.n8 CLKN_HB.n7 18.4942
R559 CLKN_HB.n22 CLKN_HB.n21 11.6805
R560 CLKN_HB.n23 CLKN_HB.n22 11.6805
R561 CLKN_HB.n17 CLKN_HB.n16 11.6805
R562 CLKN_HB.n23 CLKN_HB.n17 11.6805
R563 CLKN_HB.n21 CLKN_HB.n18 11.6805
R564 CLKN_HB.n9 CLKN_HB.n8 11.6805
R565 CLKN_HB.n10 CLKN_HB.n9 11.6805
R566 CLKN_HB.n4 CLKN_HB.n3 11.6805
R567 CLKN_HB.n10 CLKN_HB.n4 11.6805
R568 CLKN_HB.n8 CLKN_HB.n5 11.6805
R569 CLKN_HB.n34 CLKN_HB.n33 11.6805
R570 CLKN_HB.n29 CLKN_HB.n28 11.6805
R571 CLKN_HB.n26 CLKN_HB.n12 10.9291
R572 CLKN_HB.n37 CLKN_HB.n31 10.9291
R573 CLKN_HB CLKN_HB.n38 9.03615
R574 CLKN_HB.n38 CLKN_HB.n26 9.02258
R575 CLKN_HB.n26 CLKN_HB.n25 9.0005
R576 CLKN_HB.n37 CLKN_HB.n36 9.0005
R577 CLKN_HB.n20 CLKN_HB.n19 7.17687
R578 CLKN_HB.n15 CLKN_HB.n14 7.17687
R579 CLKN_HB.n7 CLKN_HB.n6 7.17687
R580 CLKN_HB.n2 CLKN_HB.n1 7.17687
R581 CLKN_HB.n36 CLKN_HB.n32 7.10487
R582 CLKN_HB.n36 CLKN_HB.n35 7.10487
R583 CLKN_HB.n31 CLKN_HB.n27 7.10487
R584 CLKN_HB.n31 CLKN_HB.n30 7.10487
R585 CLKN_HB.n38 CLKN_HB.n37 4.59693
R586 CLKN_HB.n16 CLKN_HB.n15 4.42851
R587 CLKN_HB.n19 CLKN_HB.n18 4.42851
R588 CLKN_HB.n3 CLKN_HB.n2 4.42851
R589 CLKN_HB.n6 CLKN_HB.n5 4.42851
R590 CLKN_HB.n33 CLKN_HB.n32 4.42851
R591 CLKN_HB.n35 CLKN_HB.n34 4.42851
R592 CLKN_HB.n28 CLKN_HB.n27 4.42851
R593 CLKN_HB.n30 CLKN_HB.n29 4.42851
R594 CLKN_HB.n20 CLKN_HB.n13 0.1205
R595 CLKN_HB.n24 CLKN_HB.n14 0.1205
R596 CLKN_HB.n7 CLKN_HB.n0 0.1205
R597 CLKN_HB.n11 CLKN_HB.n1 0.1205
R598 CLKN_HB.n25 CLKN_HB.n13 0.0485
R599 CLKN_HB.n25 CLKN_HB.n24 0.0485
R600 CLKN_HB.n12 CLKN_HB.n0 0.0485
R601 CLKN_HB.n12 CLKN_HB.n11 0.0485
R602 VDD.t292 VDD.t276 450.829
R603 VDD.t282 VDD.t284 450.829
R604 VDD.t306 VDD.t230 450.829
R605 VDD.t326 VDD.t358 450.829
R606 VDD.t228 VDD.t146 450.829
R607 VDD.t320 VDD.t0 450.829
R608 VDD.t260 VDD.t308 450.829
R609 VDD.t312 VDD.t252 450.829
R610 VDD.t274 VDD.t250 450.829
R611 VDD.t160 VDD.t16 450.829
R612 VDD.t316 VDD.t136 450.829
R613 VDD.t34 VDD.t22 450.829
R614 VDD.n185 VDD.t288 417.582
R615 VDD.n92 VDD.t254 417.582
R616 VDD.t288 VDD.t286 44.1994
R617 VDD.t286 VDD.t290 44.1994
R618 VDD.t290 VDD.t292 44.1994
R619 VDD.t276 VDD.t278 44.1994
R620 VDD.t278 VDD.t280 44.1994
R621 VDD.t280 VDD.t282 44.1994
R622 VDD.t284 VDD.t296 44.1994
R623 VDD.t296 VDD.t294 44.1994
R624 VDD.t294 VDD.t298 44.1994
R625 VDD.t298 VDD.t300 44.1994
R626 VDD.t300 VDD.t302 44.1994
R627 VDD.t302 VDD.t304 44.1994
R628 VDD.t304 VDD.t306 44.1994
R629 VDD.t230 VDD.t128 44.1994
R630 VDD.t128 VDD.t126 44.1994
R631 VDD.t126 VDD.t364 44.1994
R632 VDD.t364 VDD.t362 44.1994
R633 VDD.t362 VDD.t234 44.1994
R634 VDD.t234 VDD.t232 44.1994
R635 VDD.t232 VDD.t326 44.1994
R636 VDD.t358 VDD.t186 44.1994
R637 VDD.t186 VDD.t184 44.1994
R638 VDD.t184 VDD.t356 44.1994
R639 VDD.t356 VDD.t354 44.1994
R640 VDD.t354 VDD.t224 44.1994
R641 VDD.t224 VDD.t222 44.1994
R642 VDD.t222 VDD.t228 44.1994
R643 VDD.t146 VDD.t12 44.1994
R644 VDD.t12 VDD.t170 44.1994
R645 VDD.t170 VDD.t70 44.1994
R646 VDD.t70 VDD.t68 44.1994
R647 VDD.t68 VDD.t62 44.1994
R648 VDD.t62 VDD.t60 44.1994
R649 VDD.t60 VDD.t44 44.1994
R650 VDD.t44 VDD.t42 44.1994
R651 VDD.t42 VDD.t116 44.1994
R652 VDD.t116 VDD.t114 44.1994
R653 VDD.t114 VDD.t122 44.1994
R654 VDD.t122 VDD.t120 44.1994
R655 VDD.t120 VDD.t198 44.1994
R656 VDD.t198 VDD.t196 44.1994
R657 VDD.t196 VDD.t336 44.1994
R658 VDD.t336 VDD.t334 44.1994
R659 VDD.t334 VDD.t150 44.1994
R660 VDD.t150 VDD.t148 44.1994
R661 VDD.t148 VDD.t174 44.1994
R662 VDD.t174 VDD.t172 44.1994
R663 VDD.t172 VDD.t202 44.1994
R664 VDD.t202 VDD.t200 44.1994
R665 VDD.t200 VDD.t320 44.1994
R666 VDD.t0 VDD.t164 44.1994
R667 VDD.t164 VDD.t64 44.1994
R668 VDD.t64 VDD.t58 44.1994
R669 VDD.t58 VDD.t28 44.1994
R670 VDD.t28 VDD.t92 44.1994
R671 VDD.t92 VDD.t112 44.1994
R672 VDD.t112 VDD.t192 44.1994
R673 VDD.t192 VDD.t328 44.1994
R674 VDD.t328 VDD.t142 44.1994
R675 VDD.t142 VDD.t166 44.1994
R676 VDD.t166 VDD.t94 44.1994
R677 VDD.t94 VDD.t118 44.1994
R678 VDD.t118 VDD.t194 44.1994
R679 VDD.t194 VDD.t318 44.1994
R680 VDD.t318 VDD.t2 44.1994
R681 VDD.t2 VDD.t66 44.1994
R682 VDD.t66 VDD.t96 44.1994
R683 VDD.t96 VDD.t330 44.1994
R684 VDD.t330 VDD.t98 44.1994
R685 VDD.t98 VDD.t236 44.1994
R686 VDD.t236 VDD.t214 44.1994
R687 VDD.t214 VDD.t50 44.1994
R688 VDD.t50 VDD.t4 44.1994
R689 VDD.t4 VDD.t30 44.1994
R690 VDD.t30 VDD.t80 44.1994
R691 VDD.t80 VDD.t216 44.1994
R692 VDD.t216 VDD.t52 44.1994
R693 VDD.t52 VDD.t6 44.1994
R694 VDD.t6 VDD.t32 44.1994
R695 VDD.t32 VDD.t82 44.1994
R696 VDD.t82 VDD.t130 44.1994
R697 VDD.t130 VDD.t132 44.1994
R698 VDD.t132 VDD.t332 44.1994
R699 VDD.t332 VDD.t144 44.1994
R700 VDD.t144 VDD.t168 44.1994
R701 VDD.t254 VDD.t256 44.1994
R702 VDD.t256 VDD.t258 44.1994
R703 VDD.t258 VDD.t260 44.1994
R704 VDD.t308 VDD.t310 44.1994
R705 VDD.t310 VDD.t314 44.1994
R706 VDD.t314 VDD.t312 44.1994
R707 VDD.t252 VDD.t264 44.1994
R708 VDD.t264 VDD.t262 44.1994
R709 VDD.t262 VDD.t266 44.1994
R710 VDD.t266 VDD.t268 44.1994
R711 VDD.t268 VDD.t270 44.1994
R712 VDD.t270 VDD.t272 44.1994
R713 VDD.t272 VDD.t274 44.1994
R714 VDD.t250 VDD.t226 44.1994
R715 VDD.t226 VDD.t190 44.1994
R716 VDD.t190 VDD.t360 44.1994
R717 VDD.t360 VDD.t48 44.1994
R718 VDD.t48 VDD.t162 44.1994
R719 VDD.t162 VDD.t188 44.1994
R720 VDD.t188 VDD.t160 44.1994
R721 VDD.t16 VDD.t14 44.1994
R722 VDD.t14 VDD.t366 44.1994
R723 VDD.t366 VDD.t18 44.1994
R724 VDD.t18 VDD.t46 44.1994
R725 VDD.t46 VDD.t124 44.1994
R726 VDD.t124 VDD.t204 44.1994
R727 VDD.t204 VDD.t316 44.1994
R728 VDD.t136 VDD.t134 44.1994
R729 VDD.t134 VDD.t140 44.1994
R730 VDD.t140 VDD.t138 44.1994
R731 VDD.t138 VDD.t90 44.1994
R732 VDD.t90 VDD.t88 44.1994
R733 VDD.t88 VDD.t220 44.1994
R734 VDD.t220 VDD.t218 44.1994
R735 VDD.t218 VDD.t86 44.1994
R736 VDD.t86 VDD.t84 44.1994
R737 VDD.t84 VDD.t10 44.1994
R738 VDD.t10 VDD.t8 44.1994
R739 VDD.t8 VDD.t240 44.1994
R740 VDD.t240 VDD.t238 44.1994
R741 VDD.t238 VDD.t248 44.1994
R742 VDD.t248 VDD.t246 44.1994
R743 VDD.t246 VDD.t244 44.1994
R744 VDD.t244 VDD.t242 44.1994
R745 VDD.t242 VDD.t40 44.1994
R746 VDD.t40 VDD.t38 44.1994
R747 VDD.t38 VDD.t56 44.1994
R748 VDD.t56 VDD.t54 44.1994
R749 VDD.t54 VDD.t36 44.1994
R750 VDD.t36 VDD.t34 44.1994
R751 VDD.t22 VDD.t20 44.1994
R752 VDD.t20 VDD.t74 44.1994
R753 VDD.t74 VDD.t72 44.1994
R754 VDD.t72 VDD.t344 44.1994
R755 VDD.t344 VDD.t342 44.1994
R756 VDD.t342 VDD.t154 44.1994
R757 VDD.t154 VDD.t152 44.1994
R758 VDD.t152 VDD.t178 44.1994
R759 VDD.t178 VDD.t176 44.1994
R760 VDD.t176 VDD.t348 44.1994
R761 VDD.t348 VDD.t346 44.1994
R762 VDD.t346 VDD.t208 44.1994
R763 VDD.t208 VDD.t206 44.1994
R764 VDD.t206 VDD.t102 44.1994
R765 VDD.t102 VDD.t100 44.1994
R766 VDD.t100 VDD.t340 44.1994
R767 VDD.t340 VDD.t338 44.1994
R768 VDD.t338 VDD.t158 44.1994
R769 VDD.t158 VDD.t156 44.1994
R770 VDD.t156 VDD.t26 44.1994
R771 VDD.t26 VDD.t24 44.1994
R772 VDD.t24 VDD.t182 44.1994
R773 VDD.t182 VDD.t180 44.1994
R774 VDD.t180 VDD.t78 44.1994
R775 VDD.t78 VDD.t76 44.1994
R776 VDD.t76 VDD.t352 44.1994
R777 VDD.t352 VDD.t350 44.1994
R778 VDD.t350 VDD.t212 44.1994
R779 VDD.t212 VDD.t210 44.1994
R780 VDD.t210 VDD.t106 44.1994
R781 VDD.t106 VDD.t104 44.1994
R782 VDD.t104 VDD.t110 44.1994
R783 VDD.t110 VDD.t108 44.1994
R784 VDD.t108 VDD.t324 44.1994
R785 VDD.t324 VDD.t322 44.1994
R786 VDD.n152 VDD.n128 11.9797
R787 VDD.n59 VDD.n35 11.9797
R788 VDD.n152 VDD.n151 11.1661
R789 VDD.n160 VDD.n159 11.1661
R790 VDD.n168 VDD.n167 11.1661
R791 VDD.n176 VDD.n175 11.1661
R792 VDD.n180 VDD.n179 11.1661
R793 VDD.n184 VDD.n183 11.1661
R794 VDD.n59 VDD.n58 11.1661
R795 VDD.n67 VDD.n66 11.1661
R796 VDD.n75 VDD.n74 11.1661
R797 VDD.n83 VDD.n82 11.1661
R798 VDD.n87 VDD.n86 11.1661
R799 VDD.n91 VDD.n90 11.1661
R800 VDD.n96 VDD.n94 5.51014
R801 VDD.n131 VDD.n129 5.51014
R802 VDD.n155 VDD.n153 5.51014
R803 VDD.n163 VDD.n161 5.51014
R804 VDD.n171 VDD.n169 5.51014
R805 VDD.n179 VDD.n177 5.51014
R806 VDD.n183 VDD.n181 5.51014
R807 VDD.n3 VDD.n1 5.51014
R808 VDD.n38 VDD.n36 5.51014
R809 VDD.n62 VDD.n60 5.51014
R810 VDD.n70 VDD.n68 5.51014
R811 VDD.n78 VDD.n76 5.51014
R812 VDD.n86 VDD.n84 5.51014
R813 VDD.n90 VDD.n88 5.51014
R814 VDD.n128 VDD.n127 5.32067
R815 VDD.n126 VDD.n125 5.32067
R816 VDD.n124 VDD.n123 5.32067
R817 VDD.n122 VDD.n121 5.32067
R818 VDD.n120 VDD.n119 5.32067
R819 VDD.n118 VDD.n117 5.32067
R820 VDD.n116 VDD.n115 5.32067
R821 VDD.n114 VDD.n113 5.32067
R822 VDD.n112 VDD.n111 5.32067
R823 VDD.n110 VDD.n109 5.32067
R824 VDD.n108 VDD.n107 5.32067
R825 VDD.n106 VDD.n105 5.32067
R826 VDD.n104 VDD.n103 5.32067
R827 VDD.n102 VDD.n101 5.32067
R828 VDD.n100 VDD.n99 5.32067
R829 VDD.n98 VDD.n97 5.32067
R830 VDD.n96 VDD.n95 5.32067
R831 VDD.n151 VDD.n150 5.32067
R832 VDD.n149 VDD.n148 5.32067
R833 VDD.n147 VDD.n146 5.32067
R834 VDD.n145 VDD.n144 5.32067
R835 VDD.n143 VDD.n142 5.32067
R836 VDD.n141 VDD.n140 5.32067
R837 VDD.n139 VDD.n138 5.32067
R838 VDD.n137 VDD.n136 5.32067
R839 VDD.n135 VDD.n134 5.32067
R840 VDD.n133 VDD.n132 5.32067
R841 VDD.n131 VDD.n130 5.32067
R842 VDD.n159 VDD.n158 5.32067
R843 VDD.n157 VDD.n156 5.32067
R844 VDD.n155 VDD.n154 5.32067
R845 VDD.n167 VDD.n166 5.32067
R846 VDD.n165 VDD.n164 5.32067
R847 VDD.n163 VDD.n162 5.32067
R848 VDD.n175 VDD.n174 5.32067
R849 VDD.n173 VDD.n172 5.32067
R850 VDD.n171 VDD.n170 5.32067
R851 VDD.n179 VDD.n178 5.32067
R852 VDD.n183 VDD.n182 5.32067
R853 VDD.n35 VDD.n34 5.32067
R854 VDD.n33 VDD.n32 5.32067
R855 VDD.n31 VDD.n30 5.32067
R856 VDD.n29 VDD.n28 5.32067
R857 VDD.n27 VDD.n26 5.32067
R858 VDD.n25 VDD.n24 5.32067
R859 VDD.n23 VDD.n22 5.32067
R860 VDD.n21 VDD.n20 5.32067
R861 VDD.n19 VDD.n18 5.32067
R862 VDD.n17 VDD.n16 5.32067
R863 VDD.n15 VDD.n14 5.32067
R864 VDD.n13 VDD.n12 5.32067
R865 VDD.n11 VDD.n10 5.32067
R866 VDD.n9 VDD.n8 5.32067
R867 VDD.n7 VDD.n6 5.32067
R868 VDD.n5 VDD.n4 5.32067
R869 VDD.n3 VDD.n2 5.32067
R870 VDD.n58 VDD.n57 5.32067
R871 VDD.n56 VDD.n55 5.32067
R872 VDD.n54 VDD.n53 5.32067
R873 VDD.n52 VDD.n51 5.32067
R874 VDD.n50 VDD.n49 5.32067
R875 VDD.n48 VDD.n47 5.32067
R876 VDD.n46 VDD.n45 5.32067
R877 VDD.n44 VDD.n43 5.32067
R878 VDD.n42 VDD.n41 5.32067
R879 VDD.n40 VDD.n39 5.32067
R880 VDD.n38 VDD.n37 5.32067
R881 VDD.n66 VDD.n65 5.32067
R882 VDD.n64 VDD.n63 5.32067
R883 VDD.n62 VDD.n61 5.32067
R884 VDD.n74 VDD.n73 5.32067
R885 VDD.n72 VDD.n71 5.32067
R886 VDD.n70 VDD.n69 5.32067
R887 VDD.n82 VDD.n81 5.32067
R888 VDD.n80 VDD.n79 5.32067
R889 VDD.n78 VDD.n77 5.32067
R890 VDD.n86 VDD.n85 5.32067
R891 VDD.n90 VDD.n89 5.32067
R892 VDD.n93 VDD.n0 4.5005
R893 VDD.n186 VDD.n0 4.5005
R894 VDD.n93 VDD.n92 3.31749
R895 VDD.n186 VDD.n185 2.77651
R896 VDD.n188 VDD.n187 2.26839
R897 VDD VDD.n188 1.13544
R898 VDD.n160 VDD.n152 0.5981
R899 VDD.n67 VDD.n59 0.5981
R900 VDD.n180 VDD.n176 0.3101
R901 VDD.n176 VDD.n168 0.3101
R902 VDD.n168 VDD.n160 0.3101
R903 VDD.n87 VDD.n83 0.3101
R904 VDD.n83 VDD.n75 0.3101
R905 VDD.n75 VDD.n67 0.3101
R906 VDD.n185 VDD.n184 0.244205
R907 VDD.n92 VDD.n91 0.244205
R908 VDD.n184 VDD.n180 0.2381
R909 VDD.n91 VDD.n87 0.2381
R910 VDD.n127 VDD.t145 0.228
R911 VDD.n127 VDD.t169 0.228
R912 VDD.n125 VDD.t133 0.228
R913 VDD.n125 VDD.t333 0.228
R914 VDD.n123 VDD.t83 0.228
R915 VDD.n123 VDD.t131 0.228
R916 VDD.n121 VDD.t7 0.228
R917 VDD.n121 VDD.t33 0.228
R918 VDD.n119 VDD.t217 0.228
R919 VDD.n119 VDD.t53 0.228
R920 VDD.n117 VDD.t31 0.228
R921 VDD.n117 VDD.t81 0.228
R922 VDD.n115 VDD.t51 0.228
R923 VDD.n115 VDD.t5 0.228
R924 VDD.n113 VDD.t237 0.228
R925 VDD.n113 VDD.t215 0.228
R926 VDD.n111 VDD.t331 0.228
R927 VDD.n111 VDD.t99 0.228
R928 VDD.n109 VDD.t67 0.228
R929 VDD.n109 VDD.t97 0.228
R930 VDD.n107 VDD.t319 0.228
R931 VDD.n107 VDD.t3 0.228
R932 VDD.n105 VDD.t119 0.228
R933 VDD.n105 VDD.t195 0.228
R934 VDD.n103 VDD.t167 0.228
R935 VDD.n103 VDD.t95 0.228
R936 VDD.n101 VDD.t329 0.228
R937 VDD.n101 VDD.t143 0.228
R938 VDD.n99 VDD.t113 0.228
R939 VDD.n99 VDD.t193 0.228
R940 VDD.n97 VDD.t29 0.228
R941 VDD.n97 VDD.t93 0.228
R942 VDD.n95 VDD.t65 0.228
R943 VDD.n95 VDD.t59 0.228
R944 VDD.n94 VDD.t1 0.228
R945 VDD.n94 VDD.t165 0.228
R946 VDD.n150 VDD.t201 0.228
R947 VDD.n150 VDD.t321 0.228
R948 VDD.n148 VDD.t173 0.228
R949 VDD.n148 VDD.t203 0.228
R950 VDD.n146 VDD.t149 0.228
R951 VDD.n146 VDD.t175 0.228
R952 VDD.n144 VDD.t335 0.228
R953 VDD.n144 VDD.t151 0.228
R954 VDD.n142 VDD.t197 0.228
R955 VDD.n142 VDD.t337 0.228
R956 VDD.n140 VDD.t121 0.228
R957 VDD.n140 VDD.t199 0.228
R958 VDD.n138 VDD.t115 0.228
R959 VDD.n138 VDD.t123 0.228
R960 VDD.n136 VDD.t43 0.228
R961 VDD.n136 VDD.t117 0.228
R962 VDD.n134 VDD.t61 0.228
R963 VDD.n134 VDD.t45 0.228
R964 VDD.n132 VDD.t69 0.228
R965 VDD.n132 VDD.t63 0.228
R966 VDD.n130 VDD.t171 0.228
R967 VDD.n130 VDD.t71 0.228
R968 VDD.n129 VDD.t147 0.228
R969 VDD.n129 VDD.t13 0.228
R970 VDD.n158 VDD.t223 0.228
R971 VDD.n158 VDD.t229 0.228
R972 VDD.n156 VDD.t355 0.228
R973 VDD.n156 VDD.t225 0.228
R974 VDD.n154 VDD.t185 0.228
R975 VDD.n154 VDD.t357 0.228
R976 VDD.n153 VDD.t359 0.228
R977 VDD.n153 VDD.t187 0.228
R978 VDD.n166 VDD.t233 0.228
R979 VDD.n166 VDD.t327 0.228
R980 VDD.n164 VDD.t363 0.228
R981 VDD.n164 VDD.t235 0.228
R982 VDD.n162 VDD.t127 0.228
R983 VDD.n162 VDD.t365 0.228
R984 VDD.n161 VDD.t231 0.228
R985 VDD.n161 VDD.t129 0.228
R986 VDD.n174 VDD.t305 0.228
R987 VDD.n174 VDD.t307 0.228
R988 VDD.n172 VDD.t301 0.228
R989 VDD.n172 VDD.t303 0.228
R990 VDD.n170 VDD.t295 0.228
R991 VDD.n170 VDD.t299 0.228
R992 VDD.n169 VDD.t285 0.228
R993 VDD.n169 VDD.t297 0.228
R994 VDD.n178 VDD.t281 0.228
R995 VDD.n178 VDD.t283 0.228
R996 VDD.n177 VDD.t277 0.228
R997 VDD.n177 VDD.t279 0.228
R998 VDD.n182 VDD.t291 0.228
R999 VDD.n182 VDD.t293 0.228
R1000 VDD.n181 VDD.t289 0.228
R1001 VDD.n181 VDD.t287 0.228
R1002 VDD.n34 VDD.t325 0.228
R1003 VDD.n34 VDD.t323 0.228
R1004 VDD.n32 VDD.t111 0.228
R1005 VDD.n32 VDD.t109 0.228
R1006 VDD.n30 VDD.t107 0.228
R1007 VDD.n30 VDD.t105 0.228
R1008 VDD.n28 VDD.t213 0.228
R1009 VDD.n28 VDD.t211 0.228
R1010 VDD.n26 VDD.t353 0.228
R1011 VDD.n26 VDD.t351 0.228
R1012 VDD.n24 VDD.t79 0.228
R1013 VDD.n24 VDD.t77 0.228
R1014 VDD.n22 VDD.t183 0.228
R1015 VDD.n22 VDD.t181 0.228
R1016 VDD.n20 VDD.t27 0.228
R1017 VDD.n20 VDD.t25 0.228
R1018 VDD.n18 VDD.t159 0.228
R1019 VDD.n18 VDD.t157 0.228
R1020 VDD.n16 VDD.t341 0.228
R1021 VDD.n16 VDD.t339 0.228
R1022 VDD.n14 VDD.t103 0.228
R1023 VDD.n14 VDD.t101 0.228
R1024 VDD.n12 VDD.t209 0.228
R1025 VDD.n12 VDD.t207 0.228
R1026 VDD.n10 VDD.t349 0.228
R1027 VDD.n10 VDD.t347 0.228
R1028 VDD.n8 VDD.t179 0.228
R1029 VDD.n8 VDD.t177 0.228
R1030 VDD.n6 VDD.t155 0.228
R1031 VDD.n6 VDD.t153 0.228
R1032 VDD.n4 VDD.t345 0.228
R1033 VDD.n4 VDD.t343 0.228
R1034 VDD.n2 VDD.t75 0.228
R1035 VDD.n2 VDD.t73 0.228
R1036 VDD.n1 VDD.t23 0.228
R1037 VDD.n1 VDD.t21 0.228
R1038 VDD.n57 VDD.t37 0.228
R1039 VDD.n57 VDD.t35 0.228
R1040 VDD.n55 VDD.t57 0.228
R1041 VDD.n55 VDD.t55 0.228
R1042 VDD.n53 VDD.t41 0.228
R1043 VDD.n53 VDD.t39 0.228
R1044 VDD.n51 VDD.t245 0.228
R1045 VDD.n51 VDD.t243 0.228
R1046 VDD.n49 VDD.t249 0.228
R1047 VDD.n49 VDD.t247 0.228
R1048 VDD.n47 VDD.t241 0.228
R1049 VDD.n47 VDD.t239 0.228
R1050 VDD.n45 VDD.t11 0.228
R1051 VDD.n45 VDD.t9 0.228
R1052 VDD.n43 VDD.t87 0.228
R1053 VDD.n43 VDD.t85 0.228
R1054 VDD.n41 VDD.t221 0.228
R1055 VDD.n41 VDD.t219 0.228
R1056 VDD.n39 VDD.t91 0.228
R1057 VDD.n39 VDD.t89 0.228
R1058 VDD.n37 VDD.t141 0.228
R1059 VDD.n37 VDD.t139 0.228
R1060 VDD.n36 VDD.t137 0.228
R1061 VDD.n36 VDD.t135 0.228
R1062 VDD.n65 VDD.t205 0.228
R1063 VDD.n65 VDD.t317 0.228
R1064 VDD.n63 VDD.t47 0.228
R1065 VDD.n63 VDD.t125 0.228
R1066 VDD.n61 VDD.t367 0.228
R1067 VDD.n61 VDD.t19 0.228
R1068 VDD.n60 VDD.t17 0.228
R1069 VDD.n60 VDD.t15 0.228
R1070 VDD.n73 VDD.t189 0.228
R1071 VDD.n73 VDD.t161 0.228
R1072 VDD.n71 VDD.t49 0.228
R1073 VDD.n71 VDD.t163 0.228
R1074 VDD.n69 VDD.t191 0.228
R1075 VDD.n69 VDD.t361 0.228
R1076 VDD.n68 VDD.t251 0.228
R1077 VDD.n68 VDD.t227 0.228
R1078 VDD.n81 VDD.t273 0.228
R1079 VDD.n81 VDD.t275 0.228
R1080 VDD.n79 VDD.t269 0.228
R1081 VDD.n79 VDD.t271 0.228
R1082 VDD.n77 VDD.t263 0.228
R1083 VDD.n77 VDD.t267 0.228
R1084 VDD.n76 VDD.t253 0.228
R1085 VDD.n76 VDD.t265 0.228
R1086 VDD.n85 VDD.t315 0.228
R1087 VDD.n85 VDD.t313 0.228
R1088 VDD.n84 VDD.t309 0.228
R1089 VDD.n84 VDD.t311 0.228
R1090 VDD.n89 VDD.t259 0.228
R1091 VDD.n89 VDD.t261 0.228
R1092 VDD.n88 VDD.t255 0.228
R1093 VDD.n88 VDD.t257 0.228
R1094 VDD.n98 VDD.n96 0.189974
R1095 VDD.n100 VDD.n98 0.189974
R1096 VDD.n102 VDD.n100 0.189974
R1097 VDD.n104 VDD.n102 0.189974
R1098 VDD.n106 VDD.n104 0.189974
R1099 VDD.n108 VDD.n106 0.189974
R1100 VDD.n110 VDD.n108 0.189974
R1101 VDD.n112 VDD.n110 0.189974
R1102 VDD.n114 VDD.n112 0.189974
R1103 VDD.n116 VDD.n114 0.189974
R1104 VDD.n118 VDD.n116 0.189974
R1105 VDD.n120 VDD.n118 0.189974
R1106 VDD.n122 VDD.n120 0.189974
R1107 VDD.n124 VDD.n122 0.189974
R1108 VDD.n126 VDD.n124 0.189974
R1109 VDD.n128 VDD.n126 0.189974
R1110 VDD.n133 VDD.n131 0.189974
R1111 VDD.n135 VDD.n133 0.189974
R1112 VDD.n137 VDD.n135 0.189974
R1113 VDD.n139 VDD.n137 0.189974
R1114 VDD.n141 VDD.n139 0.189974
R1115 VDD.n143 VDD.n141 0.189974
R1116 VDD.n145 VDD.n143 0.189974
R1117 VDD.n147 VDD.n145 0.189974
R1118 VDD.n149 VDD.n147 0.189974
R1119 VDD.n151 VDD.n149 0.189974
R1120 VDD.n157 VDD.n155 0.189974
R1121 VDD.n159 VDD.n157 0.189974
R1122 VDD.n165 VDD.n163 0.189974
R1123 VDD.n167 VDD.n165 0.189974
R1124 VDD.n173 VDD.n171 0.189974
R1125 VDD.n175 VDD.n173 0.189974
R1126 VDD.n5 VDD.n3 0.189974
R1127 VDD.n7 VDD.n5 0.189974
R1128 VDD.n9 VDD.n7 0.189974
R1129 VDD.n11 VDD.n9 0.189974
R1130 VDD.n13 VDD.n11 0.189974
R1131 VDD.n15 VDD.n13 0.189974
R1132 VDD.n17 VDD.n15 0.189974
R1133 VDD.n19 VDD.n17 0.189974
R1134 VDD.n21 VDD.n19 0.189974
R1135 VDD.n23 VDD.n21 0.189974
R1136 VDD.n25 VDD.n23 0.189974
R1137 VDD.n27 VDD.n25 0.189974
R1138 VDD.n29 VDD.n27 0.189974
R1139 VDD.n31 VDD.n29 0.189974
R1140 VDD.n33 VDD.n31 0.189974
R1141 VDD.n35 VDD.n33 0.189974
R1142 VDD.n40 VDD.n38 0.189974
R1143 VDD.n42 VDD.n40 0.189974
R1144 VDD.n44 VDD.n42 0.189974
R1145 VDD.n46 VDD.n44 0.189974
R1146 VDD.n48 VDD.n46 0.189974
R1147 VDD.n50 VDD.n48 0.189974
R1148 VDD.n52 VDD.n50 0.189974
R1149 VDD.n54 VDD.n52 0.189974
R1150 VDD.n56 VDD.n54 0.189974
R1151 VDD.n58 VDD.n56 0.189974
R1152 VDD.n64 VDD.n62 0.189974
R1153 VDD.n66 VDD.n64 0.189974
R1154 VDD.n72 VDD.n70 0.189974
R1155 VDD.n74 VDD.n72 0.189974
R1156 VDD.n80 VDD.n78 0.189974
R1157 VDD.n82 VDD.n80 0.189974
R1158 VDD.n188 VDD.n0 0.020105
R1159 VDD.n187 VDD.n186 0.0054955
R1160 VDD.n187 VDD.n93 0.0054955
R1161 VSS.n101 VSS.n100 5121.21
R1162 VSS.n195 VSS.n101 5121.21
R1163 VSS.n98 VSS.n97 4481.41
R1164 VSS.n196 VSS.n195 4318.83
R1165 VSS.n99 VSS.n98 3545.45
R1166 VSS.n100 VSS.n99 3545.45
R1167 VSS.t264 VSS.t312 1481.56
R1168 VSS.t316 VSS.t258 1481.56
R1169 VSS.t278 VSS.t344 1481.56
R1170 VSS.t36 VSS.t112 1481.56
R1171 VSS.t338 VSS.t240 1481.56
R1172 VSS.t52 VSS.t62 1481.56
R1173 VSS.t296 VSS.t280 1481.56
R1174 VSS.t284 VSS.t294 1481.56
R1175 VSS.t310 VSS.t328 1481.56
R1176 VSS.t254 VSS.t244 1481.56
R1177 VSS.t142 VSS.t322 1481.56
R1178 VSS.t110 VSS.t144 1481.56
R1179 VSS.n4 VSS.t256 1285.47
R1180 VSS.n194 VSS.t290 1285.47
R1181 VSS.n99 VSS.n3 933.951
R1182 VSS.n100 VSS.n2 933.951
R1183 VSS.n98 VSS.n4 907.822
R1184 VSS.n195 VSS.n194 907.822
R1185 VSS.n197 VSS.n101 307.19
R1186 VSS.t256 VSS.t260 145.251
R1187 VSS.t260 VSS.t262 145.251
R1188 VSS.t262 VSS.t264 145.251
R1189 VSS.t312 VSS.t314 145.251
R1190 VSS.t314 VSS.t318 145.251
R1191 VSS.t318 VSS.t316 145.251
R1192 VSS.t258 VSS.t266 145.251
R1193 VSS.t266 VSS.t268 145.251
R1194 VSS.t268 VSS.t270 145.251
R1195 VSS.t270 VSS.t272 145.251
R1196 VSS.t272 VSS.t274 145.251
R1197 VSS.t274 VSS.t276 145.251
R1198 VSS.t276 VSS.t278 145.251
R1199 VSS.t344 VSS.t68 145.251
R1200 VSS.t68 VSS.t92 145.251
R1201 VSS.t92 VSS.t186 145.251
R1202 VSS.t186 VSS.t70 145.251
R1203 VSS.t70 VSS.t90 145.251
R1204 VSS.t90 VSS.t180 145.251
R1205 VSS.t180 VSS.t36 145.251
R1206 VSS.t112 VSS.t178 145.251
R1207 VSS.t178 VSS.t162 145.251
R1208 VSS.t162 VSS.t202 145.251
R1209 VSS.t202 VSS.t216 145.251
R1210 VSS.t216 VSS.t218 145.251
R1211 VSS.t218 VSS.t190 145.251
R1212 VSS.t190 VSS.t338 145.251
R1213 VSS.t240 VSS.t238 145.251
R1214 VSS.t238 VSS.t126 145.251
R1215 VSS.t126 VSS.t124 145.251
R1216 VSS.t124 VSS.t16 145.251
R1217 VSS.t16 VSS.t14 145.251
R1218 VSS.t14 VSS.t8 145.251
R1219 VSS.t8 VSS.t6 145.251
R1220 VSS.t6 VSS.t96 145.251
R1221 VSS.t96 VSS.t94 145.251
R1222 VSS.t94 VSS.t80 145.251
R1223 VSS.t80 VSS.t78 145.251
R1224 VSS.t78 VSS.t50 145.251
R1225 VSS.t50 VSS.t48 145.251
R1226 VSS.t48 VSS.t184 145.251
R1227 VSS.t184 VSS.t182 145.251
R1228 VSS.t182 VSS.t12 145.251
R1229 VSS.t12 VSS.t10 145.251
R1230 VSS.t10 VSS.t100 145.251
R1231 VSS.t100 VSS.t98 145.251
R1232 VSS.t98 VSS.t84 145.251
R1233 VSS.t84 VSS.t82 145.251
R1234 VSS.t82 VSS.t54 145.251
R1235 VSS.t54 VSS.t52 145.251
R1236 VSS.t62 VSS.t60 145.251
R1237 VSS.t60 VSS.t130 145.251
R1238 VSS.t130 VSS.t128 145.251
R1239 VSS.t128 VSS.t154 145.251
R1240 VSS.t154 VSS.t152 145.251
R1241 VSS.t152 VSS.t354 145.251
R1242 VSS.t354 VSS.t352 145.251
R1243 VSS.t352 VSS.t194 145.251
R1244 VSS.t194 VSS.t192 145.251
R1245 VSS.t192 VSS.t206 145.251
R1246 VSS.t206 VSS.t204 145.251
R1247 VSS.t204 VSS.t66 145.251
R1248 VSS.t66 VSS.t64 145.251
R1249 VSS.t64 VSS.t134 145.251
R1250 VSS.t134 VSS.t132 145.251
R1251 VSS.t132 VSS.t158 145.251
R1252 VSS.t158 VSS.t156 145.251
R1253 VSS.t156 VSS.t358 145.251
R1254 VSS.t358 VSS.t356 145.251
R1255 VSS.t356 VSS.t222 145.251
R1256 VSS.t222 VSS.t220 145.251
R1257 VSS.t220 VSS.t140 145.251
R1258 VSS.t140 VSS.t138 145.251
R1259 VSS.t138 VSS.t342 145.251
R1260 VSS.t342 VSS.t340 145.251
R1261 VSS.t340 VSS.t198 145.251
R1262 VSS.t198 VSS.t196 145.251
R1263 VSS.t196 VSS.t210 145.251
R1264 VSS.t210 VSS.t208 145.251
R1265 VSS.t208 VSS.t362 145.251
R1266 VSS.t362 VSS.t360 145.251
R1267 VSS.t360 VSS.t226 145.251
R1268 VSS.t226 VSS.t224 145.251
R1269 VSS.t224 VSS.t326 145.251
R1270 VSS.t326 VSS.t324 145.251
R1271 VSS.t290 VSS.t288 145.251
R1272 VSS.t288 VSS.t292 145.251
R1273 VSS.t292 VSS.t296 145.251
R1274 VSS.t280 VSS.t282 145.251
R1275 VSS.t282 VSS.t286 145.251
R1276 VSS.t286 VSS.t284 145.251
R1277 VSS.t294 VSS.t300 145.251
R1278 VSS.t300 VSS.t298 145.251
R1279 VSS.t298 VSS.t302 145.251
R1280 VSS.t302 VSS.t306 145.251
R1281 VSS.t306 VSS.t308 145.251
R1282 VSS.t308 VSS.t304 145.251
R1283 VSS.t304 VSS.t310 145.251
R1284 VSS.t328 VSS.t32 145.251
R1285 VSS.t32 VSS.t30 145.251
R1286 VSS.t30 VSS.t34 145.251
R1287 VSS.t34 VSS.t170 145.251
R1288 VSS.t170 VSS.t136 145.251
R1289 VSS.t136 VSS.t246 145.251
R1290 VSS.t246 VSS.t254 145.251
R1291 VSS.t244 VSS.t366 145.251
R1292 VSS.t366 VSS.t364 145.251
R1293 VSS.t364 VSS.t230 145.251
R1294 VSS.t230 VSS.t228 145.251
R1295 VSS.t228 VSS.t234 145.251
R1296 VSS.t234 VSS.t232 145.251
R1297 VSS.t232 VSS.t142 145.251
R1298 VSS.t322 VSS.t20 145.251
R1299 VSS.t20 VSS.t18 145.251
R1300 VSS.t18 VSS.t104 145.251
R1301 VSS.t104 VSS.t102 145.251
R1302 VSS.t102 VSS.t168 145.251
R1303 VSS.t168 VSS.t166 145.251
R1304 VSS.t166 VSS.t336 145.251
R1305 VSS.t336 VSS.t334 145.251
R1306 VSS.t334 VSS.t252 145.251
R1307 VSS.t252 VSS.t250 145.251
R1308 VSS.t250 VSS.t24 145.251
R1309 VSS.t24 VSS.t22 145.251
R1310 VSS.t22 VSS.t108 145.251
R1311 VSS.t108 VSS.t106 145.251
R1312 VSS.t106 VSS.t88 145.251
R1313 VSS.t88 VSS.t86 145.251
R1314 VSS.t86 VSS.t58 145.251
R1315 VSS.t58 VSS.t56 145.251
R1316 VSS.t56 VSS.t176 145.251
R1317 VSS.t176 VSS.t174 145.251
R1318 VSS.t174 VSS.t28 145.251
R1319 VSS.t28 VSS.t26 145.251
R1320 VSS.t26 VSS.t110 145.251
R1321 VSS.t144 VSS.t160 145.251
R1322 VSS.t160 VSS.t346 145.251
R1323 VSS.t346 VSS.t212 145.251
R1324 VSS.t212 VSS.t330 145.251
R1325 VSS.t330 VSS.t188 145.251
R1326 VSS.t188 VSS.t72 145.251
R1327 VSS.t72 VSS.t0 145.251
R1328 VSS.t0 VSS.t200 145.251
R1329 VSS.t200 VSS.t38 145.251
R1330 VSS.t38 VSS.t114 145.251
R1331 VSS.t114 VSS.t146 145.251
R1332 VSS.t146 VSS.t164 145.251
R1333 VSS.t164 VSS.t348 145.251
R1334 VSS.t348 VSS.t214 145.251
R1335 VSS.t214 VSS.t320 145.251
R1336 VSS.t320 VSS.t40 145.251
R1337 VSS.t40 VSS.t116 145.251
R1338 VSS.t116 VSS.t148 145.251
R1339 VSS.t148 VSS.t350 145.251
R1340 VSS.t350 VSS.t332 145.251
R1341 VSS.t332 VSS.t150 145.251
R1342 VSS.t150 VSS.t248 145.251
R1343 VSS.t248 VSS.t236 145.251
R1344 VSS.t236 VSS.t42 145.251
R1345 VSS.t42 VSS.t118 145.251
R1346 VSS.t118 VSS.t74 145.251
R1347 VSS.t74 VSS.t2 145.251
R1348 VSS.t2 VSS.t44 145.251
R1349 VSS.t44 VSS.t120 145.251
R1350 VSS.t120 VSS.t242 145.251
R1351 VSS.t242 VSS.t76 145.251
R1352 VSS.t76 VSS.t4 145.251
R1353 VSS.t4 VSS.t46 145.251
R1354 VSS.t46 VSS.t122 145.251
R1355 VSS.t122 VSS.t172 145.251
R1356 VSS.n96 VSS.n4 24.2224
R1357 VSS.n194 VSS.n193 24.2224
R1358 VSS.n63 VSS.n39 10.7904
R1359 VSS.n160 VSS.n136 10.7904
R1360 VSS.n63 VSS.n62 9.9768
R1361 VSS.n71 VSS.n70 9.9768
R1362 VSS.n79 VSS.n78 9.9768
R1363 VSS.n87 VSS.n86 9.9768
R1364 VSS.n91 VSS.n90 9.9768
R1365 VSS.n95 VSS.n94 9.9768
R1366 VSS.n160 VSS.n159 9.9768
R1367 VSS.n168 VSS.n167 9.9768
R1368 VSS.n176 VSS.n175 9.9768
R1369 VSS.n184 VSS.n183 9.9768
R1370 VSS.n188 VSS.n187 9.9768
R1371 VSS.n192 VSS.n191 9.9768
R1372 VSS.n7 VSS.n5 5.57485
R1373 VSS.n42 VSS.n40 5.57485
R1374 VSS.n66 VSS.n64 5.57485
R1375 VSS.n74 VSS.n72 5.57485
R1376 VSS.n82 VSS.n80 5.57485
R1377 VSS.n90 VSS.n88 5.57485
R1378 VSS.n94 VSS.n92 5.57485
R1379 VSS.n104 VSS.n102 5.57485
R1380 VSS.n139 VSS.n137 5.57485
R1381 VSS.n163 VSS.n161 5.57485
R1382 VSS.n171 VSS.n169 5.57485
R1383 VSS.n179 VSS.n177 5.57485
R1384 VSS.n187 VSS.n185 5.57485
R1385 VSS.n191 VSS.n189 5.57485
R1386 VSS.n39 VSS.n38 5.38537
R1387 VSS.n37 VSS.n36 5.38537
R1388 VSS.n35 VSS.n34 5.38537
R1389 VSS.n33 VSS.n32 5.38537
R1390 VSS.n31 VSS.n30 5.38537
R1391 VSS.n29 VSS.n28 5.38537
R1392 VSS.n27 VSS.n26 5.38537
R1393 VSS.n25 VSS.n24 5.38537
R1394 VSS.n23 VSS.n22 5.38537
R1395 VSS.n21 VSS.n20 5.38537
R1396 VSS.n19 VSS.n18 5.38537
R1397 VSS.n17 VSS.n16 5.38537
R1398 VSS.n15 VSS.n14 5.38537
R1399 VSS.n13 VSS.n12 5.38537
R1400 VSS.n11 VSS.n10 5.38537
R1401 VSS.n9 VSS.n8 5.38537
R1402 VSS.n7 VSS.n6 5.38537
R1403 VSS.n62 VSS.n61 5.38537
R1404 VSS.n60 VSS.n59 5.38537
R1405 VSS.n58 VSS.n57 5.38537
R1406 VSS.n56 VSS.n55 5.38537
R1407 VSS.n54 VSS.n53 5.38537
R1408 VSS.n52 VSS.n51 5.38537
R1409 VSS.n50 VSS.n49 5.38537
R1410 VSS.n48 VSS.n47 5.38537
R1411 VSS.n46 VSS.n45 5.38537
R1412 VSS.n44 VSS.n43 5.38537
R1413 VSS.n42 VSS.n41 5.38537
R1414 VSS.n70 VSS.n69 5.38537
R1415 VSS.n68 VSS.n67 5.38537
R1416 VSS.n66 VSS.n65 5.38537
R1417 VSS.n78 VSS.n77 5.38537
R1418 VSS.n76 VSS.n75 5.38537
R1419 VSS.n74 VSS.n73 5.38537
R1420 VSS.n86 VSS.n85 5.38537
R1421 VSS.n84 VSS.n83 5.38537
R1422 VSS.n82 VSS.n81 5.38537
R1423 VSS.n90 VSS.n89 5.38537
R1424 VSS.n94 VSS.n93 5.38537
R1425 VSS.n136 VSS.n135 5.38537
R1426 VSS.n134 VSS.n133 5.38537
R1427 VSS.n132 VSS.n131 5.38537
R1428 VSS.n130 VSS.n129 5.38537
R1429 VSS.n128 VSS.n127 5.38537
R1430 VSS.n126 VSS.n125 5.38537
R1431 VSS.n124 VSS.n123 5.38537
R1432 VSS.n122 VSS.n121 5.38537
R1433 VSS.n120 VSS.n119 5.38537
R1434 VSS.n118 VSS.n117 5.38537
R1435 VSS.n116 VSS.n115 5.38537
R1436 VSS.n114 VSS.n113 5.38537
R1437 VSS.n112 VSS.n111 5.38537
R1438 VSS.n110 VSS.n109 5.38537
R1439 VSS.n108 VSS.n107 5.38537
R1440 VSS.n106 VSS.n105 5.38537
R1441 VSS.n104 VSS.n103 5.38537
R1442 VSS.n159 VSS.n158 5.38537
R1443 VSS.n157 VSS.n156 5.38537
R1444 VSS.n155 VSS.n154 5.38537
R1445 VSS.n153 VSS.n152 5.38537
R1446 VSS.n151 VSS.n150 5.38537
R1447 VSS.n149 VSS.n148 5.38537
R1448 VSS.n147 VSS.n146 5.38537
R1449 VSS.n145 VSS.n144 5.38537
R1450 VSS.n143 VSS.n142 5.38537
R1451 VSS.n141 VSS.n140 5.38537
R1452 VSS.n139 VSS.n138 5.38537
R1453 VSS.n167 VSS.n166 5.38537
R1454 VSS.n165 VSS.n164 5.38537
R1455 VSS.n163 VSS.n162 5.38537
R1456 VSS.n175 VSS.n174 5.38537
R1457 VSS.n173 VSS.n172 5.38537
R1458 VSS.n171 VSS.n170 5.38537
R1459 VSS.n183 VSS.n182 5.38537
R1460 VSS.n181 VSS.n180 5.38537
R1461 VSS.n179 VSS.n178 5.38537
R1462 VSS.n187 VSS.n186 5.38537
R1463 VSS.n191 VSS.n190 5.38537
R1464 VSS.n1 VSS.n0 4.5005
R1465 VSS.n198 VSS.n0 4.5005
R1466 VSS.n200 VSS.n199 2.26839
R1467 VSS.n97 VSS.n96 1.90847
R1468 VSS.n196 VSS.n193 1.90847
R1469 VSS VSS.n200 1.13544
R1470 VSS.n71 VSS.n63 0.5981
R1471 VSS.n168 VSS.n160 0.5981
R1472 VSS.n97 VSS.n3 0.543479
R1473 VSS.n3 VSS.n2 0.543479
R1474 VSS.n197 VSS.n196 0.543479
R1475 VSS.n2 VSS.n1 0.507615
R1476 VSS.n198 VSS.n197 0.507363
R1477 VSS.n91 VSS.n87 0.3101
R1478 VSS.n87 VSS.n79 0.3101
R1479 VSS.n79 VSS.n71 0.3101
R1480 VSS.n188 VSS.n184 0.3101
R1481 VSS.n184 VSS.n176 0.3101
R1482 VSS.n176 VSS.n168 0.3101
R1483 VSS.n96 VSS.n95 0.244205
R1484 VSS.n193 VSS.n192 0.244205
R1485 VSS.n95 VSS.n91 0.2381
R1486 VSS.n192 VSS.n188 0.2381
R1487 VSS.n38 VSS.t327 0.20525
R1488 VSS.n38 VSS.t325 0.20525
R1489 VSS.n36 VSS.t227 0.20525
R1490 VSS.n36 VSS.t225 0.20525
R1491 VSS.n34 VSS.t363 0.20525
R1492 VSS.n34 VSS.t361 0.20525
R1493 VSS.n32 VSS.t211 0.20525
R1494 VSS.n32 VSS.t209 0.20525
R1495 VSS.n30 VSS.t199 0.20525
R1496 VSS.n30 VSS.t197 0.20525
R1497 VSS.n28 VSS.t343 0.20525
R1498 VSS.n28 VSS.t341 0.20525
R1499 VSS.n26 VSS.t141 0.20525
R1500 VSS.n26 VSS.t139 0.20525
R1501 VSS.n24 VSS.t223 0.20525
R1502 VSS.n24 VSS.t221 0.20525
R1503 VSS.n22 VSS.t359 0.20525
R1504 VSS.n22 VSS.t357 0.20525
R1505 VSS.n20 VSS.t159 0.20525
R1506 VSS.n20 VSS.t157 0.20525
R1507 VSS.n18 VSS.t135 0.20525
R1508 VSS.n18 VSS.t133 0.20525
R1509 VSS.n16 VSS.t67 0.20525
R1510 VSS.n16 VSS.t65 0.20525
R1511 VSS.n14 VSS.t207 0.20525
R1512 VSS.n14 VSS.t205 0.20525
R1513 VSS.n12 VSS.t195 0.20525
R1514 VSS.n12 VSS.t193 0.20525
R1515 VSS.n10 VSS.t355 0.20525
R1516 VSS.n10 VSS.t353 0.20525
R1517 VSS.n8 VSS.t155 0.20525
R1518 VSS.n8 VSS.t153 0.20525
R1519 VSS.n6 VSS.t131 0.20525
R1520 VSS.n6 VSS.t129 0.20525
R1521 VSS.n5 VSS.t63 0.20525
R1522 VSS.n5 VSS.t61 0.20525
R1523 VSS.n61 VSS.t55 0.20525
R1524 VSS.n61 VSS.t53 0.20525
R1525 VSS.n59 VSS.t85 0.20525
R1526 VSS.n59 VSS.t83 0.20525
R1527 VSS.n57 VSS.t101 0.20525
R1528 VSS.n57 VSS.t99 0.20525
R1529 VSS.n55 VSS.t13 0.20525
R1530 VSS.n55 VSS.t11 0.20525
R1531 VSS.n53 VSS.t185 0.20525
R1532 VSS.n53 VSS.t183 0.20525
R1533 VSS.n51 VSS.t51 0.20525
R1534 VSS.n51 VSS.t49 0.20525
R1535 VSS.n49 VSS.t81 0.20525
R1536 VSS.n49 VSS.t79 0.20525
R1537 VSS.n47 VSS.t97 0.20525
R1538 VSS.n47 VSS.t95 0.20525
R1539 VSS.n45 VSS.t9 0.20525
R1540 VSS.n45 VSS.t7 0.20525
R1541 VSS.n43 VSS.t17 0.20525
R1542 VSS.n43 VSS.t15 0.20525
R1543 VSS.n41 VSS.t127 0.20525
R1544 VSS.n41 VSS.t125 0.20525
R1545 VSS.n40 VSS.t241 0.20525
R1546 VSS.n40 VSS.t239 0.20525
R1547 VSS.n69 VSS.t191 0.20525
R1548 VSS.n69 VSS.t339 0.20525
R1549 VSS.n67 VSS.t217 0.20525
R1550 VSS.n67 VSS.t219 0.20525
R1551 VSS.n65 VSS.t163 0.20525
R1552 VSS.n65 VSS.t203 0.20525
R1553 VSS.n64 VSS.t113 0.20525
R1554 VSS.n64 VSS.t179 0.20525
R1555 VSS.n77 VSS.t181 0.20525
R1556 VSS.n77 VSS.t37 0.20525
R1557 VSS.n75 VSS.t71 0.20525
R1558 VSS.n75 VSS.t91 0.20525
R1559 VSS.n73 VSS.t93 0.20525
R1560 VSS.n73 VSS.t187 0.20525
R1561 VSS.n72 VSS.t345 0.20525
R1562 VSS.n72 VSS.t69 0.20525
R1563 VSS.n85 VSS.t277 0.20525
R1564 VSS.n85 VSS.t279 0.20525
R1565 VSS.n83 VSS.t273 0.20525
R1566 VSS.n83 VSS.t275 0.20525
R1567 VSS.n81 VSS.t269 0.20525
R1568 VSS.n81 VSS.t271 0.20525
R1569 VSS.n80 VSS.t259 0.20525
R1570 VSS.n80 VSS.t267 0.20525
R1571 VSS.n89 VSS.t319 0.20525
R1572 VSS.n89 VSS.t317 0.20525
R1573 VSS.n88 VSS.t313 0.20525
R1574 VSS.n88 VSS.t315 0.20525
R1575 VSS.n93 VSS.t263 0.20525
R1576 VSS.n93 VSS.t265 0.20525
R1577 VSS.n92 VSS.t257 0.20525
R1578 VSS.n92 VSS.t261 0.20525
R1579 VSS.n135 VSS.t123 0.20525
R1580 VSS.n135 VSS.t173 0.20525
R1581 VSS.n133 VSS.t5 0.20525
R1582 VSS.n133 VSS.t47 0.20525
R1583 VSS.n131 VSS.t243 0.20525
R1584 VSS.n131 VSS.t77 0.20525
R1585 VSS.n129 VSS.t45 0.20525
R1586 VSS.n129 VSS.t121 0.20525
R1587 VSS.n127 VSS.t75 0.20525
R1588 VSS.n127 VSS.t3 0.20525
R1589 VSS.n125 VSS.t43 0.20525
R1590 VSS.n125 VSS.t119 0.20525
R1591 VSS.n123 VSS.t249 0.20525
R1592 VSS.n123 VSS.t237 0.20525
R1593 VSS.n121 VSS.t333 0.20525
R1594 VSS.n121 VSS.t151 0.20525
R1595 VSS.n119 VSS.t149 0.20525
R1596 VSS.n119 VSS.t351 0.20525
R1597 VSS.n117 VSS.t41 0.20525
R1598 VSS.n117 VSS.t117 0.20525
R1599 VSS.n115 VSS.t215 0.20525
R1600 VSS.n115 VSS.t321 0.20525
R1601 VSS.n113 VSS.t165 0.20525
R1602 VSS.n113 VSS.t349 0.20525
R1603 VSS.n111 VSS.t115 0.20525
R1604 VSS.n111 VSS.t147 0.20525
R1605 VSS.n109 VSS.t201 0.20525
R1606 VSS.n109 VSS.t39 0.20525
R1607 VSS.n107 VSS.t73 0.20525
R1608 VSS.n107 VSS.t1 0.20525
R1609 VSS.n105 VSS.t331 0.20525
R1610 VSS.n105 VSS.t189 0.20525
R1611 VSS.n103 VSS.t347 0.20525
R1612 VSS.n103 VSS.t213 0.20525
R1613 VSS.n102 VSS.t145 0.20525
R1614 VSS.n102 VSS.t161 0.20525
R1615 VSS.n158 VSS.t27 0.20525
R1616 VSS.n158 VSS.t111 0.20525
R1617 VSS.n156 VSS.t175 0.20525
R1618 VSS.n156 VSS.t29 0.20525
R1619 VSS.n154 VSS.t57 0.20525
R1620 VSS.n154 VSS.t177 0.20525
R1621 VSS.n152 VSS.t87 0.20525
R1622 VSS.n152 VSS.t59 0.20525
R1623 VSS.n150 VSS.t107 0.20525
R1624 VSS.n150 VSS.t89 0.20525
R1625 VSS.n148 VSS.t23 0.20525
R1626 VSS.n148 VSS.t109 0.20525
R1627 VSS.n146 VSS.t251 0.20525
R1628 VSS.n146 VSS.t25 0.20525
R1629 VSS.n144 VSS.t335 0.20525
R1630 VSS.n144 VSS.t253 0.20525
R1631 VSS.n142 VSS.t167 0.20525
R1632 VSS.n142 VSS.t337 0.20525
R1633 VSS.n140 VSS.t103 0.20525
R1634 VSS.n140 VSS.t169 0.20525
R1635 VSS.n138 VSS.t19 0.20525
R1636 VSS.n138 VSS.t105 0.20525
R1637 VSS.n137 VSS.t323 0.20525
R1638 VSS.n137 VSS.t21 0.20525
R1639 VSS.n166 VSS.t233 0.20525
R1640 VSS.n166 VSS.t143 0.20525
R1641 VSS.n164 VSS.t229 0.20525
R1642 VSS.n164 VSS.t235 0.20525
R1643 VSS.n162 VSS.t365 0.20525
R1644 VSS.n162 VSS.t231 0.20525
R1645 VSS.n161 VSS.t245 0.20525
R1646 VSS.n161 VSS.t367 0.20525
R1647 VSS.n174 VSS.t247 0.20525
R1648 VSS.n174 VSS.t255 0.20525
R1649 VSS.n172 VSS.t171 0.20525
R1650 VSS.n172 VSS.t137 0.20525
R1651 VSS.n170 VSS.t31 0.20525
R1652 VSS.n170 VSS.t35 0.20525
R1653 VSS.n169 VSS.t329 0.20525
R1654 VSS.n169 VSS.t33 0.20525
R1655 VSS.n182 VSS.t305 0.20525
R1656 VSS.n182 VSS.t311 0.20525
R1657 VSS.n180 VSS.t307 0.20525
R1658 VSS.n180 VSS.t309 0.20525
R1659 VSS.n178 VSS.t299 0.20525
R1660 VSS.n178 VSS.t303 0.20525
R1661 VSS.n177 VSS.t295 0.20525
R1662 VSS.n177 VSS.t301 0.20525
R1663 VSS.n186 VSS.t287 0.20525
R1664 VSS.n186 VSS.t285 0.20525
R1665 VSS.n185 VSS.t281 0.20525
R1666 VSS.n185 VSS.t283 0.20525
R1667 VSS.n190 VSS.t293 0.20525
R1668 VSS.n190 VSS.t297 0.20525
R1669 VSS.n189 VSS.t291 0.20525
R1670 VSS.n189 VSS.t289 0.20525
R1671 VSS.n9 VSS.n7 0.189974
R1672 VSS.n11 VSS.n9 0.189974
R1673 VSS.n13 VSS.n11 0.189974
R1674 VSS.n15 VSS.n13 0.189974
R1675 VSS.n17 VSS.n15 0.189974
R1676 VSS.n19 VSS.n17 0.189974
R1677 VSS.n21 VSS.n19 0.189974
R1678 VSS.n23 VSS.n21 0.189974
R1679 VSS.n25 VSS.n23 0.189974
R1680 VSS.n27 VSS.n25 0.189974
R1681 VSS.n29 VSS.n27 0.189974
R1682 VSS.n31 VSS.n29 0.189974
R1683 VSS.n33 VSS.n31 0.189974
R1684 VSS.n35 VSS.n33 0.189974
R1685 VSS.n37 VSS.n35 0.189974
R1686 VSS.n39 VSS.n37 0.189974
R1687 VSS.n44 VSS.n42 0.189974
R1688 VSS.n46 VSS.n44 0.189974
R1689 VSS.n48 VSS.n46 0.189974
R1690 VSS.n50 VSS.n48 0.189974
R1691 VSS.n52 VSS.n50 0.189974
R1692 VSS.n54 VSS.n52 0.189974
R1693 VSS.n56 VSS.n54 0.189974
R1694 VSS.n58 VSS.n56 0.189974
R1695 VSS.n60 VSS.n58 0.189974
R1696 VSS.n62 VSS.n60 0.189974
R1697 VSS.n68 VSS.n66 0.189974
R1698 VSS.n70 VSS.n68 0.189974
R1699 VSS.n76 VSS.n74 0.189974
R1700 VSS.n78 VSS.n76 0.189974
R1701 VSS.n84 VSS.n82 0.189974
R1702 VSS.n86 VSS.n84 0.189974
R1703 VSS.n106 VSS.n104 0.189974
R1704 VSS.n108 VSS.n106 0.189974
R1705 VSS.n110 VSS.n108 0.189974
R1706 VSS.n112 VSS.n110 0.189974
R1707 VSS.n114 VSS.n112 0.189974
R1708 VSS.n116 VSS.n114 0.189974
R1709 VSS.n118 VSS.n116 0.189974
R1710 VSS.n120 VSS.n118 0.189974
R1711 VSS.n122 VSS.n120 0.189974
R1712 VSS.n124 VSS.n122 0.189974
R1713 VSS.n126 VSS.n124 0.189974
R1714 VSS.n128 VSS.n126 0.189974
R1715 VSS.n130 VSS.n128 0.189974
R1716 VSS.n132 VSS.n130 0.189974
R1717 VSS.n134 VSS.n132 0.189974
R1718 VSS.n136 VSS.n134 0.189974
R1719 VSS.n141 VSS.n139 0.189974
R1720 VSS.n143 VSS.n141 0.189974
R1721 VSS.n145 VSS.n143 0.189974
R1722 VSS.n147 VSS.n145 0.189974
R1723 VSS.n149 VSS.n147 0.189974
R1724 VSS.n151 VSS.n149 0.189974
R1725 VSS.n153 VSS.n151 0.189974
R1726 VSS.n155 VSS.n153 0.189974
R1727 VSS.n157 VSS.n155 0.189974
R1728 VSS.n159 VSS.n157 0.189974
R1729 VSS.n165 VSS.n163 0.189974
R1730 VSS.n167 VSS.n165 0.189974
R1731 VSS.n173 VSS.n171 0.189974
R1732 VSS.n175 VSS.n173 0.189974
R1733 VSS.n181 VSS.n179 0.189974
R1734 VSS.n183 VSS.n181 0.189974
R1735 VSS.n200 VSS.n0 0.020105
R1736 VSS.n199 VSS.n198 0.0054955
R1737 VSS.n199 VSS.n1 0.0054955
R1738 a_15180_6400.n122 a_15180_6400.t83 113.632
R1739 a_15180_6400.n146 a_15180_6400.t48 113.632
R1740 a_15180_6400.n53 a_15180_6400.t119 113.632
R1741 a_15180_6400.n77 a_15180_6400.t84 113.632
R1742 a_15180_6400.n171 a_15180_6400.t65 109.174
R1743 a_15180_6400.n172 a_15180_6400.t66 109.174
R1744 a_15180_6400.n123 a_15180_6400.t82 109.174
R1745 a_15180_6400.n124 a_15180_6400.t81 109.174
R1746 a_15180_6400.n125 a_15180_6400.t80 109.174
R1747 a_15180_6400.n126 a_15180_6400.t79 109.174
R1748 a_15180_6400.n127 a_15180_6400.t78 109.174
R1749 a_15180_6400.n128 a_15180_6400.t77 109.174
R1750 a_15180_6400.n129 a_15180_6400.t76 109.174
R1751 a_15180_6400.n130 a_15180_6400.t75 109.174
R1752 a_15180_6400.n131 a_15180_6400.t74 109.174
R1753 a_15180_6400.n132 a_15180_6400.t73 109.174
R1754 a_15180_6400.n133 a_15180_6400.t72 109.174
R1755 a_15180_6400.n134 a_15180_6400.t71 109.174
R1756 a_15180_6400.n135 a_15180_6400.t70 109.174
R1757 a_15180_6400.n136 a_15180_6400.t69 109.174
R1758 a_15180_6400.n137 a_15180_6400.t68 109.174
R1759 a_15180_6400.n138 a_15180_6400.t67 109.174
R1760 a_15180_6400.n170 a_15180_6400.t64 109.174
R1761 a_15180_6400.n139 a_15180_6400.t63 109.174
R1762 a_15180_6400.n166 a_15180_6400.t62 109.174
R1763 a_15180_6400.n165 a_15180_6400.t61 109.174
R1764 a_15180_6400.n164 a_15180_6400.t60 109.174
R1765 a_15180_6400.n141 a_15180_6400.t59 109.174
R1766 a_15180_6400.n160 a_15180_6400.t58 109.174
R1767 a_15180_6400.n159 a_15180_6400.t57 109.174
R1768 a_15180_6400.n158 a_15180_6400.t56 109.174
R1769 a_15180_6400.n143 a_15180_6400.t55 109.174
R1770 a_15180_6400.n154 a_15180_6400.t54 109.174
R1771 a_15180_6400.n153 a_15180_6400.t53 109.174
R1772 a_15180_6400.n152 a_15180_6400.t52 109.174
R1773 a_15180_6400.n145 a_15180_6400.t51 109.174
R1774 a_15180_6400.n148 a_15180_6400.t50 109.174
R1775 a_15180_6400.n147 a_15180_6400.t49 109.174
R1776 a_15180_6400.n102 a_15180_6400.t101 109.174
R1777 a_15180_6400.n103 a_15180_6400.t102 109.174
R1778 a_15180_6400.n54 a_15180_6400.t118 109.174
R1779 a_15180_6400.n55 a_15180_6400.t117 109.174
R1780 a_15180_6400.n56 a_15180_6400.t116 109.174
R1781 a_15180_6400.n57 a_15180_6400.t115 109.174
R1782 a_15180_6400.n58 a_15180_6400.t114 109.174
R1783 a_15180_6400.n59 a_15180_6400.t113 109.174
R1784 a_15180_6400.n60 a_15180_6400.t112 109.174
R1785 a_15180_6400.n61 a_15180_6400.t111 109.174
R1786 a_15180_6400.n62 a_15180_6400.t110 109.174
R1787 a_15180_6400.n63 a_15180_6400.t109 109.174
R1788 a_15180_6400.n64 a_15180_6400.t108 109.174
R1789 a_15180_6400.n65 a_15180_6400.t107 109.174
R1790 a_15180_6400.n66 a_15180_6400.t106 109.174
R1791 a_15180_6400.n67 a_15180_6400.t105 109.174
R1792 a_15180_6400.n68 a_15180_6400.t104 109.174
R1793 a_15180_6400.n69 a_15180_6400.t103 109.174
R1794 a_15180_6400.n101 a_15180_6400.t100 109.174
R1795 a_15180_6400.n70 a_15180_6400.t99 109.174
R1796 a_15180_6400.n97 a_15180_6400.t98 109.174
R1797 a_15180_6400.n96 a_15180_6400.t97 109.174
R1798 a_15180_6400.n95 a_15180_6400.t96 109.174
R1799 a_15180_6400.n72 a_15180_6400.t95 109.174
R1800 a_15180_6400.n91 a_15180_6400.t94 109.174
R1801 a_15180_6400.n90 a_15180_6400.t93 109.174
R1802 a_15180_6400.n89 a_15180_6400.t92 109.174
R1803 a_15180_6400.n74 a_15180_6400.t91 109.174
R1804 a_15180_6400.n85 a_15180_6400.t90 109.174
R1805 a_15180_6400.n84 a_15180_6400.t89 109.174
R1806 a_15180_6400.n83 a_15180_6400.t88 109.174
R1807 a_15180_6400.n76 a_15180_6400.t87 109.174
R1808 a_15180_6400.n79 a_15180_6400.t86 109.174
R1809 a_15180_6400.n78 a_15180_6400.t85 109.174
R1810 a_15180_6400.n171 a_15180_6400.n106 18.4942
R1811 a_15180_6400.n173 a_15180_6400.n172 18.4942
R1812 a_15180_6400.n124 a_15180_6400.n121 18.4942
R1813 a_15180_6400.n125 a_15180_6400.n120 18.4942
R1814 a_15180_6400.n126 a_15180_6400.n119 18.4942
R1815 a_15180_6400.n127 a_15180_6400.n118 18.4942
R1816 a_15180_6400.n128 a_15180_6400.n117 18.4942
R1817 a_15180_6400.n129 a_15180_6400.n116 18.4942
R1818 a_15180_6400.n130 a_15180_6400.n115 18.4942
R1819 a_15180_6400.n131 a_15180_6400.n114 18.4942
R1820 a_15180_6400.n132 a_15180_6400.n113 18.4942
R1821 a_15180_6400.n133 a_15180_6400.n112 18.4942
R1822 a_15180_6400.n134 a_15180_6400.n111 18.4942
R1823 a_15180_6400.n135 a_15180_6400.n110 18.4942
R1824 a_15180_6400.n136 a_15180_6400.n109 18.4942
R1825 a_15180_6400.n137 a_15180_6400.n108 18.4942
R1826 a_15180_6400.n138 a_15180_6400.n107 18.4942
R1827 a_15180_6400.n170 a_15180_6400.n169 18.4942
R1828 a_15180_6400.n168 a_15180_6400.n139 18.4942
R1829 a_15180_6400.n167 a_15180_6400.n166 18.4942
R1830 a_15180_6400.n165 a_15180_6400.n140 18.4942
R1831 a_15180_6400.n164 a_15180_6400.n163 18.4942
R1832 a_15180_6400.n162 a_15180_6400.n141 18.4942
R1833 a_15180_6400.n161 a_15180_6400.n160 18.4942
R1834 a_15180_6400.n159 a_15180_6400.n142 18.4942
R1835 a_15180_6400.n158 a_15180_6400.n157 18.4942
R1836 a_15180_6400.n156 a_15180_6400.n143 18.4942
R1837 a_15180_6400.n155 a_15180_6400.n154 18.4942
R1838 a_15180_6400.n153 a_15180_6400.n144 18.4942
R1839 a_15180_6400.n152 a_15180_6400.n151 18.4942
R1840 a_15180_6400.n150 a_15180_6400.n145 18.4942
R1841 a_15180_6400.n149 a_15180_6400.n148 18.4942
R1842 a_15180_6400.n102 a_15180_6400.n37 18.4942
R1843 a_15180_6400.n104 a_15180_6400.n103 18.4942
R1844 a_15180_6400.n55 a_15180_6400.n52 18.4942
R1845 a_15180_6400.n56 a_15180_6400.n51 18.4942
R1846 a_15180_6400.n57 a_15180_6400.n50 18.4942
R1847 a_15180_6400.n58 a_15180_6400.n49 18.4942
R1848 a_15180_6400.n59 a_15180_6400.n48 18.4942
R1849 a_15180_6400.n60 a_15180_6400.n47 18.4942
R1850 a_15180_6400.n61 a_15180_6400.n46 18.4942
R1851 a_15180_6400.n62 a_15180_6400.n45 18.4942
R1852 a_15180_6400.n63 a_15180_6400.n44 18.4942
R1853 a_15180_6400.n64 a_15180_6400.n43 18.4942
R1854 a_15180_6400.n65 a_15180_6400.n42 18.4942
R1855 a_15180_6400.n66 a_15180_6400.n41 18.4942
R1856 a_15180_6400.n67 a_15180_6400.n40 18.4942
R1857 a_15180_6400.n68 a_15180_6400.n39 18.4942
R1858 a_15180_6400.n69 a_15180_6400.n38 18.4942
R1859 a_15180_6400.n101 a_15180_6400.n100 18.4942
R1860 a_15180_6400.n99 a_15180_6400.n70 18.4942
R1861 a_15180_6400.n98 a_15180_6400.n97 18.4942
R1862 a_15180_6400.n96 a_15180_6400.n71 18.4942
R1863 a_15180_6400.n95 a_15180_6400.n94 18.4942
R1864 a_15180_6400.n93 a_15180_6400.n72 18.4942
R1865 a_15180_6400.n92 a_15180_6400.n91 18.4942
R1866 a_15180_6400.n90 a_15180_6400.n73 18.4942
R1867 a_15180_6400.n89 a_15180_6400.n88 18.4942
R1868 a_15180_6400.n87 a_15180_6400.n74 18.4942
R1869 a_15180_6400.n86 a_15180_6400.n85 18.4942
R1870 a_15180_6400.n84 a_15180_6400.n75 18.4942
R1871 a_15180_6400.n83 a_15180_6400.n82 18.4942
R1872 a_15180_6400.n81 a_15180_6400.n76 18.4942
R1873 a_15180_6400.n80 a_15180_6400.n79 18.4942
R1874 a_15180_6400.n176 a_15180_6400.n175 18.2054
R1875 a_15180_6400.n171 a_15180_6400.n170 11.6805
R1876 a_15180_6400.n172 a_15180_6400.n171 11.6805
R1877 a_15180_6400.n124 a_15180_6400.n123 11.6805
R1878 a_15180_6400.n125 a_15180_6400.n124 11.6805
R1879 a_15180_6400.n126 a_15180_6400.n125 11.6805
R1880 a_15180_6400.n127 a_15180_6400.n126 11.6805
R1881 a_15180_6400.n128 a_15180_6400.n127 11.6805
R1882 a_15180_6400.n129 a_15180_6400.n128 11.6805
R1883 a_15180_6400.n130 a_15180_6400.n129 11.6805
R1884 a_15180_6400.n131 a_15180_6400.n130 11.6805
R1885 a_15180_6400.n132 a_15180_6400.n131 11.6805
R1886 a_15180_6400.n133 a_15180_6400.n132 11.6805
R1887 a_15180_6400.n134 a_15180_6400.n133 11.6805
R1888 a_15180_6400.n135 a_15180_6400.n134 11.6805
R1889 a_15180_6400.n136 a_15180_6400.n135 11.6805
R1890 a_15180_6400.n137 a_15180_6400.n136 11.6805
R1891 a_15180_6400.n138 a_15180_6400.n137 11.6805
R1892 a_15180_6400.n172 a_15180_6400.n138 11.6805
R1893 a_15180_6400.n170 a_15180_6400.n139 11.6805
R1894 a_15180_6400.n166 a_15180_6400.n139 11.6805
R1895 a_15180_6400.n166 a_15180_6400.n165 11.6805
R1896 a_15180_6400.n165 a_15180_6400.n164 11.6805
R1897 a_15180_6400.n164 a_15180_6400.n141 11.6805
R1898 a_15180_6400.n160 a_15180_6400.n141 11.6805
R1899 a_15180_6400.n160 a_15180_6400.n159 11.6805
R1900 a_15180_6400.n159 a_15180_6400.n158 11.6805
R1901 a_15180_6400.n158 a_15180_6400.n143 11.6805
R1902 a_15180_6400.n154 a_15180_6400.n143 11.6805
R1903 a_15180_6400.n154 a_15180_6400.n153 11.6805
R1904 a_15180_6400.n153 a_15180_6400.n152 11.6805
R1905 a_15180_6400.n152 a_15180_6400.n145 11.6805
R1906 a_15180_6400.n148 a_15180_6400.n145 11.6805
R1907 a_15180_6400.n148 a_15180_6400.n147 11.6805
R1908 a_15180_6400.n102 a_15180_6400.n101 11.6805
R1909 a_15180_6400.n103 a_15180_6400.n102 11.6805
R1910 a_15180_6400.n55 a_15180_6400.n54 11.6805
R1911 a_15180_6400.n56 a_15180_6400.n55 11.6805
R1912 a_15180_6400.n57 a_15180_6400.n56 11.6805
R1913 a_15180_6400.n58 a_15180_6400.n57 11.6805
R1914 a_15180_6400.n59 a_15180_6400.n58 11.6805
R1915 a_15180_6400.n60 a_15180_6400.n59 11.6805
R1916 a_15180_6400.n61 a_15180_6400.n60 11.6805
R1917 a_15180_6400.n62 a_15180_6400.n61 11.6805
R1918 a_15180_6400.n63 a_15180_6400.n62 11.6805
R1919 a_15180_6400.n64 a_15180_6400.n63 11.6805
R1920 a_15180_6400.n65 a_15180_6400.n64 11.6805
R1921 a_15180_6400.n66 a_15180_6400.n65 11.6805
R1922 a_15180_6400.n67 a_15180_6400.n66 11.6805
R1923 a_15180_6400.n68 a_15180_6400.n67 11.6805
R1924 a_15180_6400.n69 a_15180_6400.n68 11.6805
R1925 a_15180_6400.n103 a_15180_6400.n69 11.6805
R1926 a_15180_6400.n101 a_15180_6400.n70 11.6805
R1927 a_15180_6400.n97 a_15180_6400.n70 11.6805
R1928 a_15180_6400.n97 a_15180_6400.n96 11.6805
R1929 a_15180_6400.n96 a_15180_6400.n95 11.6805
R1930 a_15180_6400.n95 a_15180_6400.n72 11.6805
R1931 a_15180_6400.n91 a_15180_6400.n72 11.6805
R1932 a_15180_6400.n91 a_15180_6400.n90 11.6805
R1933 a_15180_6400.n90 a_15180_6400.n89 11.6805
R1934 a_15180_6400.n89 a_15180_6400.n74 11.6805
R1935 a_15180_6400.n85 a_15180_6400.n74 11.6805
R1936 a_15180_6400.n85 a_15180_6400.n84 11.6805
R1937 a_15180_6400.n84 a_15180_6400.n83 11.6805
R1938 a_15180_6400.n83 a_15180_6400.n76 11.6805
R1939 a_15180_6400.n79 a_15180_6400.n76 11.6805
R1940 a_15180_6400.n79 a_15180_6400.n78 11.6805
R1941 a_15180_6400.n175 a_15180_6400.n105 10.688
R1942 a_15180_6400.n175 a_15180_6400.n174 9.24157
R1943 a_15180_6400.n149 a_15180_6400.n146 7.17687
R1944 a_15180_6400.n122 a_15180_6400.n121 7.17687
R1945 a_15180_6400.n80 a_15180_6400.n77 7.17687
R1946 a_15180_6400.n53 a_15180_6400.n52 7.17687
R1947 a_15180_6400.n176 a_15180_6400.n36 6.5392
R1948 a_15180_6400.n1 a_15180_6400.t12 5.7796
R1949 a_15180_6400.n15 a_15180_6400.t8 5.73764
R1950 a_15180_6400.n177 a_15180_6400.t39 5.59012
R1951 a_15180_6400.n36 a_15180_6400.t35 5.54817
R1952 a_15180_6400.n185 a_15180_6400.n184 5.38537
R1953 a_15180_6400.n1 a_15180_6400.n0 5.38537
R1954 a_15180_6400.n3 a_15180_6400.n2 5.38537
R1955 a_15180_6400.n5 a_15180_6400.n4 5.38537
R1956 a_15180_6400.n7 a_15180_6400.n6 5.38537
R1957 a_15180_6400.n9 a_15180_6400.n8 5.38537
R1958 a_15180_6400.n11 a_15180_6400.n10 5.38537
R1959 a_15180_6400.n13 a_15180_6400.n12 5.38537
R1960 a_15180_6400.n183 a_15180_6400.n182 5.38537
R1961 a_15180_6400.n181 a_15180_6400.n180 5.38537
R1962 a_15180_6400.n179 a_15180_6400.n178 5.38537
R1963 a_15180_6400.n15 a_15180_6400.n14 5.32067
R1964 a_15180_6400.n17 a_15180_6400.n16 5.32067
R1965 a_15180_6400.n19 a_15180_6400.n18 5.32067
R1966 a_15180_6400.n21 a_15180_6400.n20 5.32067
R1967 a_15180_6400.n23 a_15180_6400.n22 5.32067
R1968 a_15180_6400.n25 a_15180_6400.n24 5.32067
R1969 a_15180_6400.n27 a_15180_6400.n26 5.32067
R1970 a_15180_6400.n29 a_15180_6400.n28 5.32067
R1971 a_15180_6400.n31 a_15180_6400.n30 5.32067
R1972 a_15180_6400.n33 a_15180_6400.n32 5.32067
R1973 a_15180_6400.n35 a_15180_6400.n34 5.32067
R1974 a_15180_6400.n177 a_15180_6400.n176 4.61063
R1975 a_15180_6400.n123 a_15180_6400.n122 4.42851
R1976 a_15180_6400.n147 a_15180_6400.n146 4.42851
R1977 a_15180_6400.n54 a_15180_6400.n53 4.42851
R1978 a_15180_6400.n78 a_15180_6400.n77 4.42851
R1979 a_15180_6400.n14 a_15180_6400.t16 0.228
R1980 a_15180_6400.n14 a_15180_6400.t9 0.228
R1981 a_15180_6400.n16 a_15180_6400.t14 0.228
R1982 a_15180_6400.n16 a_15180_6400.t17 0.228
R1983 a_15180_6400.n18 a_15180_6400.t44 0.228
R1984 a_15180_6400.n18 a_15180_6400.t15 0.228
R1985 a_15180_6400.n20 a_15180_6400.t46 0.228
R1986 a_15180_6400.n20 a_15180_6400.t45 0.228
R1987 a_15180_6400.n22 a_15180_6400.t42 0.228
R1988 a_15180_6400.n22 a_15180_6400.t47 0.228
R1989 a_15180_6400.n24 a_15180_6400.t6 0.228
R1990 a_15180_6400.n24 a_15180_6400.t43 0.228
R1991 a_15180_6400.n26 a_15180_6400.t26 0.228
R1992 a_15180_6400.n26 a_15180_6400.t7 0.228
R1993 a_15180_6400.n28 a_15180_6400.t40 0.228
R1994 a_15180_6400.n28 a_15180_6400.t27 0.228
R1995 a_15180_6400.n30 a_15180_6400.t28 0.228
R1996 a_15180_6400.n30 a_15180_6400.t41 0.228
R1997 a_15180_6400.n32 a_15180_6400.t36 0.228
R1998 a_15180_6400.n32 a_15180_6400.t29 0.228
R1999 a_15180_6400.n34 a_15180_6400.t34 0.228
R2000 a_15180_6400.n34 a_15180_6400.t37 0.228
R2001 a_15180_6400.t0 a_15180_6400.n185 0.20525
R2002 a_15180_6400.n185 a_15180_6400.t23 0.20525
R2003 a_15180_6400.n0 a_15180_6400.t20 0.20525
R2004 a_15180_6400.n0 a_15180_6400.t13 0.20525
R2005 a_15180_6400.n2 a_15180_6400.t24 0.20525
R2006 a_15180_6400.n2 a_15180_6400.t21 0.20525
R2007 a_15180_6400.n4 a_15180_6400.t2 0.20525
R2008 a_15180_6400.n4 a_15180_6400.t25 0.20525
R2009 a_15180_6400.n6 a_15180_6400.t32 0.20525
R2010 a_15180_6400.n6 a_15180_6400.t3 0.20525
R2011 a_15180_6400.n8 a_15180_6400.t10 0.20525
R2012 a_15180_6400.n8 a_15180_6400.t33 0.20525
R2013 a_15180_6400.n10 a_15180_6400.t18 0.20525
R2014 a_15180_6400.n10 a_15180_6400.t11 0.20525
R2015 a_15180_6400.n12 a_15180_6400.t22 0.20525
R2016 a_15180_6400.n12 a_15180_6400.t19 0.20525
R2017 a_15180_6400.n182 a_15180_6400.t4 0.20525
R2018 a_15180_6400.n182 a_15180_6400.t1 0.20525
R2019 a_15180_6400.n180 a_15180_6400.t30 0.20525
R2020 a_15180_6400.n180 a_15180_6400.t5 0.20525
R2021 a_15180_6400.n178 a_15180_6400.t38 0.20525
R2022 a_15180_6400.n178 a_15180_6400.t31 0.20525
R2023 a_15180_6400.n179 a_15180_6400.n177 0.189974
R2024 a_15180_6400.n181 a_15180_6400.n179 0.189974
R2025 a_15180_6400.n183 a_15180_6400.n181 0.189974
R2026 a_15180_6400.n184 a_15180_6400.n183 0.189974
R2027 a_15180_6400.n184 a_15180_6400.n13 0.189974
R2028 a_15180_6400.n13 a_15180_6400.n11 0.189974
R2029 a_15180_6400.n11 a_15180_6400.n9 0.189974
R2030 a_15180_6400.n9 a_15180_6400.n7 0.189974
R2031 a_15180_6400.n7 a_15180_6400.n5 0.189974
R2032 a_15180_6400.n5 a_15180_6400.n3 0.189974
R2033 a_15180_6400.n3 a_15180_6400.n1 0.189974
R2034 a_15180_6400.n36 a_15180_6400.n35 0.189974
R2035 a_15180_6400.n35 a_15180_6400.n33 0.189974
R2036 a_15180_6400.n33 a_15180_6400.n31 0.189974
R2037 a_15180_6400.n31 a_15180_6400.n29 0.189974
R2038 a_15180_6400.n29 a_15180_6400.n27 0.189974
R2039 a_15180_6400.n27 a_15180_6400.n25 0.189974
R2040 a_15180_6400.n25 a_15180_6400.n23 0.189974
R2041 a_15180_6400.n23 a_15180_6400.n21 0.189974
R2042 a_15180_6400.n21 a_15180_6400.n19 0.189974
R2043 a_15180_6400.n19 a_15180_6400.n17 0.189974
R2044 a_15180_6400.n17 a_15180_6400.n15 0.189974
R2045 a_15180_6400.n169 a_15180_6400.n106 0.1205
R2046 a_15180_6400.n169 a_15180_6400.n168 0.1205
R2047 a_15180_6400.n168 a_15180_6400.n167 0.1205
R2048 a_15180_6400.n167 a_15180_6400.n140 0.1205
R2049 a_15180_6400.n163 a_15180_6400.n140 0.1205
R2050 a_15180_6400.n163 a_15180_6400.n162 0.1205
R2051 a_15180_6400.n162 a_15180_6400.n161 0.1205
R2052 a_15180_6400.n161 a_15180_6400.n142 0.1205
R2053 a_15180_6400.n157 a_15180_6400.n142 0.1205
R2054 a_15180_6400.n157 a_15180_6400.n156 0.1205
R2055 a_15180_6400.n156 a_15180_6400.n155 0.1205
R2056 a_15180_6400.n155 a_15180_6400.n144 0.1205
R2057 a_15180_6400.n151 a_15180_6400.n144 0.1205
R2058 a_15180_6400.n151 a_15180_6400.n150 0.1205
R2059 a_15180_6400.n150 a_15180_6400.n149 0.1205
R2060 a_15180_6400.n121 a_15180_6400.n120 0.1205
R2061 a_15180_6400.n120 a_15180_6400.n119 0.1205
R2062 a_15180_6400.n119 a_15180_6400.n118 0.1205
R2063 a_15180_6400.n118 a_15180_6400.n117 0.1205
R2064 a_15180_6400.n117 a_15180_6400.n116 0.1205
R2065 a_15180_6400.n116 a_15180_6400.n115 0.1205
R2066 a_15180_6400.n115 a_15180_6400.n114 0.1205
R2067 a_15180_6400.n114 a_15180_6400.n113 0.1205
R2068 a_15180_6400.n113 a_15180_6400.n112 0.1205
R2069 a_15180_6400.n112 a_15180_6400.n111 0.1205
R2070 a_15180_6400.n111 a_15180_6400.n110 0.1205
R2071 a_15180_6400.n110 a_15180_6400.n109 0.1205
R2072 a_15180_6400.n109 a_15180_6400.n108 0.1205
R2073 a_15180_6400.n108 a_15180_6400.n107 0.1205
R2074 a_15180_6400.n173 a_15180_6400.n107 0.1205
R2075 a_15180_6400.n100 a_15180_6400.n37 0.1205
R2076 a_15180_6400.n100 a_15180_6400.n99 0.1205
R2077 a_15180_6400.n99 a_15180_6400.n98 0.1205
R2078 a_15180_6400.n98 a_15180_6400.n71 0.1205
R2079 a_15180_6400.n94 a_15180_6400.n71 0.1205
R2080 a_15180_6400.n94 a_15180_6400.n93 0.1205
R2081 a_15180_6400.n93 a_15180_6400.n92 0.1205
R2082 a_15180_6400.n92 a_15180_6400.n73 0.1205
R2083 a_15180_6400.n88 a_15180_6400.n73 0.1205
R2084 a_15180_6400.n88 a_15180_6400.n87 0.1205
R2085 a_15180_6400.n87 a_15180_6400.n86 0.1205
R2086 a_15180_6400.n86 a_15180_6400.n75 0.1205
R2087 a_15180_6400.n82 a_15180_6400.n75 0.1205
R2088 a_15180_6400.n82 a_15180_6400.n81 0.1205
R2089 a_15180_6400.n81 a_15180_6400.n80 0.1205
R2090 a_15180_6400.n52 a_15180_6400.n51 0.1205
R2091 a_15180_6400.n51 a_15180_6400.n50 0.1205
R2092 a_15180_6400.n50 a_15180_6400.n49 0.1205
R2093 a_15180_6400.n49 a_15180_6400.n48 0.1205
R2094 a_15180_6400.n48 a_15180_6400.n47 0.1205
R2095 a_15180_6400.n47 a_15180_6400.n46 0.1205
R2096 a_15180_6400.n46 a_15180_6400.n45 0.1205
R2097 a_15180_6400.n45 a_15180_6400.n44 0.1205
R2098 a_15180_6400.n44 a_15180_6400.n43 0.1205
R2099 a_15180_6400.n43 a_15180_6400.n42 0.1205
R2100 a_15180_6400.n42 a_15180_6400.n41 0.1205
R2101 a_15180_6400.n41 a_15180_6400.n40 0.1205
R2102 a_15180_6400.n40 a_15180_6400.n39 0.1205
R2103 a_15180_6400.n39 a_15180_6400.n38 0.1205
R2104 a_15180_6400.n104 a_15180_6400.n38 0.1205
R2105 a_15180_6400.n174 a_15180_6400.n106 0.0485
R2106 a_15180_6400.n174 a_15180_6400.n173 0.0485
R2107 a_15180_6400.n105 a_15180_6400.n37 0.0485
R2108 a_15180_6400.n105 a_15180_6400.n104 0.0485
R2109 a_6924_6400.n62 a_6924_6400.t39 113.632
R2110 a_6924_6400.n78 a_6924_6400.t16 113.632
R2111 a_6924_6400.n17 a_6924_6400.t63 113.632
R2112 a_6924_6400.n33 a_6924_6400.t40 113.632
R2113 a_6924_6400.n93 a_6924_6400.t27 109.174
R2114 a_6924_6400.n94 a_6924_6400.t28 109.174
R2115 a_6924_6400.n63 a_6924_6400.t38 109.174
R2116 a_6924_6400.n64 a_6924_6400.t37 109.174
R2117 a_6924_6400.n65 a_6924_6400.t36 109.174
R2118 a_6924_6400.n66 a_6924_6400.t35 109.174
R2119 a_6924_6400.n67 a_6924_6400.t34 109.174
R2120 a_6924_6400.n68 a_6924_6400.t33 109.174
R2121 a_6924_6400.n69 a_6924_6400.t32 109.174
R2122 a_6924_6400.n70 a_6924_6400.t31 109.174
R2123 a_6924_6400.n71 a_6924_6400.t30 109.174
R2124 a_6924_6400.n72 a_6924_6400.t29 109.174
R2125 a_6924_6400.n92 a_6924_6400.t26 109.174
R2126 a_6924_6400.n73 a_6924_6400.t25 109.174
R2127 a_6924_6400.n88 a_6924_6400.t24 109.174
R2128 a_6924_6400.n87 a_6924_6400.t23 109.174
R2129 a_6924_6400.n86 a_6924_6400.t22 109.174
R2130 a_6924_6400.n75 a_6924_6400.t21 109.174
R2131 a_6924_6400.n82 a_6924_6400.t20 109.174
R2132 a_6924_6400.n81 a_6924_6400.t19 109.174
R2133 a_6924_6400.n80 a_6924_6400.t18 109.174
R2134 a_6924_6400.n77 a_6924_6400.t17 109.174
R2135 a_6924_6400.n48 a_6924_6400.t51 109.174
R2136 a_6924_6400.n49 a_6924_6400.t52 109.174
R2137 a_6924_6400.n18 a_6924_6400.t62 109.174
R2138 a_6924_6400.n19 a_6924_6400.t61 109.174
R2139 a_6924_6400.n20 a_6924_6400.t60 109.174
R2140 a_6924_6400.n21 a_6924_6400.t59 109.174
R2141 a_6924_6400.n22 a_6924_6400.t58 109.174
R2142 a_6924_6400.n23 a_6924_6400.t57 109.174
R2143 a_6924_6400.n24 a_6924_6400.t56 109.174
R2144 a_6924_6400.n25 a_6924_6400.t55 109.174
R2145 a_6924_6400.n26 a_6924_6400.t54 109.174
R2146 a_6924_6400.n27 a_6924_6400.t53 109.174
R2147 a_6924_6400.n47 a_6924_6400.t50 109.174
R2148 a_6924_6400.n28 a_6924_6400.t49 109.174
R2149 a_6924_6400.n43 a_6924_6400.t48 109.174
R2150 a_6924_6400.n42 a_6924_6400.t47 109.174
R2151 a_6924_6400.n41 a_6924_6400.t46 109.174
R2152 a_6924_6400.n30 a_6924_6400.t45 109.174
R2153 a_6924_6400.n37 a_6924_6400.t44 109.174
R2154 a_6924_6400.n36 a_6924_6400.t43 109.174
R2155 a_6924_6400.n35 a_6924_6400.t42 109.174
R2156 a_6924_6400.n32 a_6924_6400.t41 109.174
R2157 a_6924_6400.n98 a_6924_6400.n97 19.4712
R2158 a_6924_6400.n93 a_6924_6400.n52 18.4942
R2159 a_6924_6400.n95 a_6924_6400.n94 18.4942
R2160 a_6924_6400.n64 a_6924_6400.n61 18.4942
R2161 a_6924_6400.n65 a_6924_6400.n60 18.4942
R2162 a_6924_6400.n66 a_6924_6400.n59 18.4942
R2163 a_6924_6400.n67 a_6924_6400.n58 18.4942
R2164 a_6924_6400.n68 a_6924_6400.n57 18.4942
R2165 a_6924_6400.n69 a_6924_6400.n56 18.4942
R2166 a_6924_6400.n70 a_6924_6400.n55 18.4942
R2167 a_6924_6400.n71 a_6924_6400.n54 18.4942
R2168 a_6924_6400.n72 a_6924_6400.n53 18.4942
R2169 a_6924_6400.n92 a_6924_6400.n91 18.4942
R2170 a_6924_6400.n90 a_6924_6400.n73 18.4942
R2171 a_6924_6400.n89 a_6924_6400.n88 18.4942
R2172 a_6924_6400.n87 a_6924_6400.n74 18.4942
R2173 a_6924_6400.n86 a_6924_6400.n85 18.4942
R2174 a_6924_6400.n84 a_6924_6400.n75 18.4942
R2175 a_6924_6400.n83 a_6924_6400.n82 18.4942
R2176 a_6924_6400.n81 a_6924_6400.n76 18.4942
R2177 a_6924_6400.n80 a_6924_6400.n79 18.4942
R2178 a_6924_6400.n48 a_6924_6400.n7 18.4942
R2179 a_6924_6400.n50 a_6924_6400.n49 18.4942
R2180 a_6924_6400.n19 a_6924_6400.n16 18.4942
R2181 a_6924_6400.n20 a_6924_6400.n15 18.4942
R2182 a_6924_6400.n21 a_6924_6400.n14 18.4942
R2183 a_6924_6400.n22 a_6924_6400.n13 18.4942
R2184 a_6924_6400.n23 a_6924_6400.n12 18.4942
R2185 a_6924_6400.n24 a_6924_6400.n11 18.4942
R2186 a_6924_6400.n25 a_6924_6400.n10 18.4942
R2187 a_6924_6400.n26 a_6924_6400.n9 18.4942
R2188 a_6924_6400.n27 a_6924_6400.n8 18.4942
R2189 a_6924_6400.n47 a_6924_6400.n46 18.4942
R2190 a_6924_6400.n45 a_6924_6400.n28 18.4942
R2191 a_6924_6400.n44 a_6924_6400.n43 18.4942
R2192 a_6924_6400.n42 a_6924_6400.n29 18.4942
R2193 a_6924_6400.n41 a_6924_6400.n40 18.4942
R2194 a_6924_6400.n39 a_6924_6400.n30 18.4942
R2195 a_6924_6400.n38 a_6924_6400.n37 18.4942
R2196 a_6924_6400.n36 a_6924_6400.n31 18.4942
R2197 a_6924_6400.n35 a_6924_6400.n34 18.4942
R2198 a_6924_6400.n93 a_6924_6400.n92 11.6805
R2199 a_6924_6400.n94 a_6924_6400.n93 11.6805
R2200 a_6924_6400.n64 a_6924_6400.n63 11.6805
R2201 a_6924_6400.n65 a_6924_6400.n64 11.6805
R2202 a_6924_6400.n66 a_6924_6400.n65 11.6805
R2203 a_6924_6400.n67 a_6924_6400.n66 11.6805
R2204 a_6924_6400.n68 a_6924_6400.n67 11.6805
R2205 a_6924_6400.n69 a_6924_6400.n68 11.6805
R2206 a_6924_6400.n70 a_6924_6400.n69 11.6805
R2207 a_6924_6400.n71 a_6924_6400.n70 11.6805
R2208 a_6924_6400.n72 a_6924_6400.n71 11.6805
R2209 a_6924_6400.n94 a_6924_6400.n72 11.6805
R2210 a_6924_6400.n92 a_6924_6400.n73 11.6805
R2211 a_6924_6400.n88 a_6924_6400.n73 11.6805
R2212 a_6924_6400.n88 a_6924_6400.n87 11.6805
R2213 a_6924_6400.n87 a_6924_6400.n86 11.6805
R2214 a_6924_6400.n86 a_6924_6400.n75 11.6805
R2215 a_6924_6400.n82 a_6924_6400.n75 11.6805
R2216 a_6924_6400.n82 a_6924_6400.n81 11.6805
R2217 a_6924_6400.n81 a_6924_6400.n80 11.6805
R2218 a_6924_6400.n80 a_6924_6400.n77 11.6805
R2219 a_6924_6400.n48 a_6924_6400.n47 11.6805
R2220 a_6924_6400.n49 a_6924_6400.n48 11.6805
R2221 a_6924_6400.n19 a_6924_6400.n18 11.6805
R2222 a_6924_6400.n20 a_6924_6400.n19 11.6805
R2223 a_6924_6400.n21 a_6924_6400.n20 11.6805
R2224 a_6924_6400.n22 a_6924_6400.n21 11.6805
R2225 a_6924_6400.n23 a_6924_6400.n22 11.6805
R2226 a_6924_6400.n24 a_6924_6400.n23 11.6805
R2227 a_6924_6400.n25 a_6924_6400.n24 11.6805
R2228 a_6924_6400.n26 a_6924_6400.n25 11.6805
R2229 a_6924_6400.n27 a_6924_6400.n26 11.6805
R2230 a_6924_6400.n49 a_6924_6400.n27 11.6805
R2231 a_6924_6400.n47 a_6924_6400.n28 11.6805
R2232 a_6924_6400.n43 a_6924_6400.n28 11.6805
R2233 a_6924_6400.n43 a_6924_6400.n42 11.6805
R2234 a_6924_6400.n42 a_6924_6400.n41 11.6805
R2235 a_6924_6400.n41 a_6924_6400.n30 11.6805
R2236 a_6924_6400.n37 a_6924_6400.n30 11.6805
R2237 a_6924_6400.n37 a_6924_6400.n36 11.6805
R2238 a_6924_6400.n36 a_6924_6400.n35 11.6805
R2239 a_6924_6400.n35 a_6924_6400.n32 11.6805
R2240 a_6924_6400.n97 a_6924_6400.n51 10.013
R2241 a_6924_6400.n97 a_6924_6400.n96 9.91657
R2242 a_6924_6400.n79 a_6924_6400.n78 7.17687
R2243 a_6924_6400.n62 a_6924_6400.n61 7.17687
R2244 a_6924_6400.n34 a_6924_6400.n33 7.17687
R2245 a_6924_6400.n17 a_6924_6400.n16 7.17687
R2246 a_6924_6400.n98 a_6924_6400.n6 6.5392
R2247 a_6924_6400.t7 a_6924_6400.n105 5.7796
R2248 a_6924_6400.n1 a_6924_6400.t15 5.73764
R2249 a_6924_6400.n99 a_6924_6400.t0 5.59012
R2250 a_6924_6400.n6 a_6924_6400.t8 5.54817
R2251 a_6924_6400.n105 a_6924_6400.n104 5.38537
R2252 a_6924_6400.n103 a_6924_6400.n102 5.38537
R2253 a_6924_6400.n101 a_6924_6400.n100 5.38537
R2254 a_6924_6400.n1 a_6924_6400.n0 5.32067
R2255 a_6924_6400.n3 a_6924_6400.n2 5.32067
R2256 a_6924_6400.n5 a_6924_6400.n4 5.32067
R2257 a_6924_6400.n99 a_6924_6400.n98 4.61063
R2258 a_6924_6400.n63 a_6924_6400.n62 4.42851
R2259 a_6924_6400.n78 a_6924_6400.n77 4.42851
R2260 a_6924_6400.n18 a_6924_6400.n17 4.42851
R2261 a_6924_6400.n33 a_6924_6400.n32 4.42851
R2262 a_6924_6400.n0 a_6924_6400.t13 0.228
R2263 a_6924_6400.n0 a_6924_6400.t14 0.228
R2264 a_6924_6400.n2 a_6924_6400.t11 0.228
R2265 a_6924_6400.n2 a_6924_6400.t12 0.228
R2266 a_6924_6400.n4 a_6924_6400.t9 0.228
R2267 a_6924_6400.n4 a_6924_6400.t10 0.228
R2268 a_6924_6400.n104 a_6924_6400.t5 0.20525
R2269 a_6924_6400.n104 a_6924_6400.t6 0.20525
R2270 a_6924_6400.n102 a_6924_6400.t3 0.20525
R2271 a_6924_6400.n102 a_6924_6400.t4 0.20525
R2272 a_6924_6400.n100 a_6924_6400.t1 0.20525
R2273 a_6924_6400.n100 a_6924_6400.t2 0.20525
R2274 a_6924_6400.n101 a_6924_6400.n99 0.189974
R2275 a_6924_6400.n103 a_6924_6400.n101 0.189974
R2276 a_6924_6400.n105 a_6924_6400.n103 0.189974
R2277 a_6924_6400.n6 a_6924_6400.n5 0.189974
R2278 a_6924_6400.n5 a_6924_6400.n3 0.189974
R2279 a_6924_6400.n3 a_6924_6400.n1 0.189974
R2280 a_6924_6400.n91 a_6924_6400.n52 0.1205
R2281 a_6924_6400.n91 a_6924_6400.n90 0.1205
R2282 a_6924_6400.n90 a_6924_6400.n89 0.1205
R2283 a_6924_6400.n89 a_6924_6400.n74 0.1205
R2284 a_6924_6400.n85 a_6924_6400.n74 0.1205
R2285 a_6924_6400.n85 a_6924_6400.n84 0.1205
R2286 a_6924_6400.n84 a_6924_6400.n83 0.1205
R2287 a_6924_6400.n83 a_6924_6400.n76 0.1205
R2288 a_6924_6400.n79 a_6924_6400.n76 0.1205
R2289 a_6924_6400.n61 a_6924_6400.n60 0.1205
R2290 a_6924_6400.n60 a_6924_6400.n59 0.1205
R2291 a_6924_6400.n59 a_6924_6400.n58 0.1205
R2292 a_6924_6400.n58 a_6924_6400.n57 0.1205
R2293 a_6924_6400.n57 a_6924_6400.n56 0.1205
R2294 a_6924_6400.n56 a_6924_6400.n55 0.1205
R2295 a_6924_6400.n55 a_6924_6400.n54 0.1205
R2296 a_6924_6400.n54 a_6924_6400.n53 0.1205
R2297 a_6924_6400.n95 a_6924_6400.n53 0.1205
R2298 a_6924_6400.n46 a_6924_6400.n7 0.1205
R2299 a_6924_6400.n46 a_6924_6400.n45 0.1205
R2300 a_6924_6400.n45 a_6924_6400.n44 0.1205
R2301 a_6924_6400.n44 a_6924_6400.n29 0.1205
R2302 a_6924_6400.n40 a_6924_6400.n29 0.1205
R2303 a_6924_6400.n40 a_6924_6400.n39 0.1205
R2304 a_6924_6400.n39 a_6924_6400.n38 0.1205
R2305 a_6924_6400.n38 a_6924_6400.n31 0.1205
R2306 a_6924_6400.n34 a_6924_6400.n31 0.1205
R2307 a_6924_6400.n16 a_6924_6400.n15 0.1205
R2308 a_6924_6400.n15 a_6924_6400.n14 0.1205
R2309 a_6924_6400.n14 a_6924_6400.n13 0.1205
R2310 a_6924_6400.n13 a_6924_6400.n12 0.1205
R2311 a_6924_6400.n12 a_6924_6400.n11 0.1205
R2312 a_6924_6400.n11 a_6924_6400.n10 0.1205
R2313 a_6924_6400.n10 a_6924_6400.n9 0.1205
R2314 a_6924_6400.n9 a_6924_6400.n8 0.1205
R2315 a_6924_6400.n50 a_6924_6400.n8 0.1205
R2316 a_6924_6400.n96 a_6924_6400.n52 0.0485
R2317 a_6924_6400.n96 a_6924_6400.n95 0.0485
R2318 a_6924_6400.n51 a_6924_6400.n7 0.0485
R2319 a_6924_6400.n51 a_6924_6400.n50 0.0485
R2320 a_4812_6400.n18 a_4812_6400.t15 113.632
R2321 a_4812_6400.n22 a_4812_6400.t8 113.632
R2322 a_4812_6400.n5 a_4812_6400.t23 113.632
R2323 a_4812_6400.n9 a_4812_6400.t16 113.632
R2324 a_4812_6400.n25 a_4812_6400.t11 109.174
R2325 a_4812_6400.n26 a_4812_6400.t12 109.174
R2326 a_4812_6400.n19 a_4812_6400.t14 109.174
R2327 a_4812_6400.n20 a_4812_6400.t13 109.174
R2328 a_4812_6400.n24 a_4812_6400.t10 109.174
R2329 a_4812_6400.n21 a_4812_6400.t9 109.174
R2330 a_4812_6400.n12 a_4812_6400.t19 109.174
R2331 a_4812_6400.n13 a_4812_6400.t20 109.174
R2332 a_4812_6400.n6 a_4812_6400.t22 109.174
R2333 a_4812_6400.n7 a_4812_6400.t21 109.174
R2334 a_4812_6400.n11 a_4812_6400.t18 109.174
R2335 a_4812_6400.n8 a_4812_6400.t17 109.174
R2336 a_4812_6400.n25 a_4812_6400.n16 18.4942
R2337 a_4812_6400.n27 a_4812_6400.n26 18.4942
R2338 a_4812_6400.n20 a_4812_6400.n17 18.4942
R2339 a_4812_6400.n24 a_4812_6400.n23 18.4942
R2340 a_4812_6400.n12 a_4812_6400.n3 18.4942
R2341 a_4812_6400.n14 a_4812_6400.n13 18.4942
R2342 a_4812_6400.n7 a_4812_6400.n4 18.4942
R2343 a_4812_6400.n11 a_4812_6400.n10 18.4942
R2344 a_4812_6400.n30 a_4812_6400.n29 17.9305
R2345 a_4812_6400.n25 a_4812_6400.n24 11.6805
R2346 a_4812_6400.n26 a_4812_6400.n25 11.6805
R2347 a_4812_6400.n20 a_4812_6400.n19 11.6805
R2348 a_4812_6400.n26 a_4812_6400.n20 11.6805
R2349 a_4812_6400.n24 a_4812_6400.n21 11.6805
R2350 a_4812_6400.n12 a_4812_6400.n11 11.6805
R2351 a_4812_6400.n13 a_4812_6400.n12 11.6805
R2352 a_4812_6400.n7 a_4812_6400.n6 11.6805
R2353 a_4812_6400.n13 a_4812_6400.n7 11.6805
R2354 a_4812_6400.n11 a_4812_6400.n8 11.6805
R2355 a_4812_6400.n29 a_4812_6400.n15 10.3505
R2356 a_4812_6400.n29 a_4812_6400.n28 9.57907
R2357 a_4812_6400.n23 a_4812_6400.n22 7.17687
R2358 a_4812_6400.n18 a_4812_6400.n17 7.17687
R2359 a_4812_6400.n10 a_4812_6400.n9 7.17687
R2360 a_4812_6400.n5 a_4812_6400.n4 7.17687
R2361 a_4812_6400.n30 a_4812_6400.n2 6.5392
R2362 a_4812_6400.t3 a_4812_6400.n33 5.7796
R2363 a_4812_6400.n1 a_4812_6400.t7 5.73764
R2364 a_4812_6400.n31 a_4812_6400.t0 5.59012
R2365 a_4812_6400.n2 a_4812_6400.t4 5.54817
R2366 a_4812_6400.n33 a_4812_6400.n32 5.38537
R2367 a_4812_6400.n1 a_4812_6400.n0 5.32067
R2368 a_4812_6400.n31 a_4812_6400.n30 4.61063
R2369 a_4812_6400.n19 a_4812_6400.n18 4.42851
R2370 a_4812_6400.n22 a_4812_6400.n21 4.42851
R2371 a_4812_6400.n6 a_4812_6400.n5 4.42851
R2372 a_4812_6400.n9 a_4812_6400.n8 4.42851
R2373 a_4812_6400.n0 a_4812_6400.t5 0.228
R2374 a_4812_6400.n0 a_4812_6400.t6 0.228
R2375 a_4812_6400.n32 a_4812_6400.t1 0.20525
R2376 a_4812_6400.n32 a_4812_6400.t2 0.20525
R2377 a_4812_6400.n33 a_4812_6400.n31 0.189974
R2378 a_4812_6400.n2 a_4812_6400.n1 0.189974
R2379 a_4812_6400.n23 a_4812_6400.n16 0.1205
R2380 a_4812_6400.n27 a_4812_6400.n17 0.1205
R2381 a_4812_6400.n10 a_4812_6400.n3 0.1205
R2382 a_4812_6400.n14 a_4812_6400.n4 0.1205
R2383 a_4812_6400.n28 a_4812_6400.n16 0.0485
R2384 a_4812_6400.n28 a_4812_6400.n27 0.0485
R2385 a_4812_6400.n15 a_4812_6400.n3 0.0485
R2386 a_4812_6400.n15 a_4812_6400.n14 0.0485
R2387 a_2700_6400.n18 a_2700_6400.t15 113.632
R2388 a_2700_6400.n22 a_2700_6400.t8 113.632
R2389 a_2700_6400.n5 a_2700_6400.t23 113.632
R2390 a_2700_6400.n9 a_2700_6400.t16 113.632
R2391 a_2700_6400.n25 a_2700_6400.t11 109.174
R2392 a_2700_6400.n26 a_2700_6400.t12 109.174
R2393 a_2700_6400.n19 a_2700_6400.t14 109.174
R2394 a_2700_6400.n20 a_2700_6400.t13 109.174
R2395 a_2700_6400.n24 a_2700_6400.t10 109.174
R2396 a_2700_6400.n21 a_2700_6400.t9 109.174
R2397 a_2700_6400.n12 a_2700_6400.t19 109.174
R2398 a_2700_6400.n13 a_2700_6400.t20 109.174
R2399 a_2700_6400.n6 a_2700_6400.t22 109.174
R2400 a_2700_6400.n7 a_2700_6400.t21 109.174
R2401 a_2700_6400.n11 a_2700_6400.t18 109.174
R2402 a_2700_6400.n8 a_2700_6400.t17 109.174
R2403 a_2700_6400.n25 a_2700_6400.n16 18.4942
R2404 a_2700_6400.n27 a_2700_6400.n26 18.4942
R2405 a_2700_6400.n20 a_2700_6400.n17 18.4942
R2406 a_2700_6400.n24 a_2700_6400.n23 18.4942
R2407 a_2700_6400.n12 a_2700_6400.n3 18.4942
R2408 a_2700_6400.n14 a_2700_6400.n13 18.4942
R2409 a_2700_6400.n7 a_2700_6400.n4 18.4942
R2410 a_2700_6400.n11 a_2700_6400.n10 18.4942
R2411 a_2700_6400.n30 a_2700_6400.n29 17.6419
R2412 a_2700_6400.n25 a_2700_6400.n24 11.6805
R2413 a_2700_6400.n26 a_2700_6400.n25 11.6805
R2414 a_2700_6400.n20 a_2700_6400.n19 11.6805
R2415 a_2700_6400.n26 a_2700_6400.n20 11.6805
R2416 a_2700_6400.n24 a_2700_6400.n21 11.6805
R2417 a_2700_6400.n12 a_2700_6400.n11 11.6805
R2418 a_2700_6400.n13 a_2700_6400.n12 11.6805
R2419 a_2700_6400.n7 a_2700_6400.n6 11.6805
R2420 a_2700_6400.n13 a_2700_6400.n7 11.6805
R2421 a_2700_6400.n11 a_2700_6400.n8 11.6805
R2422 a_2700_6400.n29 a_2700_6400.n15 10.688
R2423 a_2700_6400.n29 a_2700_6400.n28 9.24157
R2424 a_2700_6400.n23 a_2700_6400.n22 7.17687
R2425 a_2700_6400.n18 a_2700_6400.n17 7.17687
R2426 a_2700_6400.n10 a_2700_6400.n9 7.17687
R2427 a_2700_6400.n5 a_2700_6400.n4 7.17687
R2428 a_2700_6400.n30 a_2700_6400.n2 6.5392
R2429 a_2700_6400.t3 a_2700_6400.n33 5.7796
R2430 a_2700_6400.n1 a_2700_6400.t7 5.73764
R2431 a_2700_6400.n31 a_2700_6400.t0 5.59012
R2432 a_2700_6400.n2 a_2700_6400.t4 5.54817
R2433 a_2700_6400.n33 a_2700_6400.n32 5.38537
R2434 a_2700_6400.n1 a_2700_6400.n0 5.32067
R2435 a_2700_6400.n31 a_2700_6400.n30 4.61063
R2436 a_2700_6400.n19 a_2700_6400.n18 4.42851
R2437 a_2700_6400.n22 a_2700_6400.n21 4.42851
R2438 a_2700_6400.n6 a_2700_6400.n5 4.42851
R2439 a_2700_6400.n9 a_2700_6400.n8 4.42851
R2440 a_2700_6400.n0 a_2700_6400.t5 0.228
R2441 a_2700_6400.n0 a_2700_6400.t6 0.228
R2442 a_2700_6400.n32 a_2700_6400.t1 0.20525
R2443 a_2700_6400.n32 a_2700_6400.t2 0.20525
R2444 a_2700_6400.n33 a_2700_6400.n31 0.189974
R2445 a_2700_6400.n2 a_2700_6400.n1 0.189974
R2446 a_2700_6400.n23 a_2700_6400.n16 0.1205
R2447 a_2700_6400.n27 a_2700_6400.n17 0.1205
R2448 a_2700_6400.n10 a_2700_6400.n3 0.1205
R2449 a_2700_6400.n14 a_2700_6400.n4 0.1205
R2450 a_2700_6400.n28 a_2700_6400.n16 0.0485
R2451 a_2700_6400.n28 a_2700_6400.n27 0.0485
R2452 a_2700_6400.n15 a_2700_6400.n3 0.0485
R2453 a_2700_6400.n15 a_2700_6400.n14 0.0485
R2454 a_15180_41600.n105 a_15180_41600.t83 113.632
R2455 a_15180_41600.n129 a_15180_41600.t48 113.632
R2456 a_15180_41600.n36 a_15180_41600.t119 113.632
R2457 a_15180_41600.n60 a_15180_41600.t84 113.632
R2458 a_15180_41600.n154 a_15180_41600.t65 109.174
R2459 a_15180_41600.n155 a_15180_41600.t66 109.174
R2460 a_15180_41600.n106 a_15180_41600.t82 109.174
R2461 a_15180_41600.n107 a_15180_41600.t81 109.174
R2462 a_15180_41600.n108 a_15180_41600.t80 109.174
R2463 a_15180_41600.n109 a_15180_41600.t79 109.174
R2464 a_15180_41600.n110 a_15180_41600.t78 109.174
R2465 a_15180_41600.n111 a_15180_41600.t77 109.174
R2466 a_15180_41600.n112 a_15180_41600.t76 109.174
R2467 a_15180_41600.n113 a_15180_41600.t75 109.174
R2468 a_15180_41600.n114 a_15180_41600.t74 109.174
R2469 a_15180_41600.n115 a_15180_41600.t73 109.174
R2470 a_15180_41600.n116 a_15180_41600.t72 109.174
R2471 a_15180_41600.n117 a_15180_41600.t71 109.174
R2472 a_15180_41600.n118 a_15180_41600.t70 109.174
R2473 a_15180_41600.n119 a_15180_41600.t69 109.174
R2474 a_15180_41600.n120 a_15180_41600.t68 109.174
R2475 a_15180_41600.n121 a_15180_41600.t67 109.174
R2476 a_15180_41600.n153 a_15180_41600.t64 109.174
R2477 a_15180_41600.n122 a_15180_41600.t63 109.174
R2478 a_15180_41600.n149 a_15180_41600.t62 109.174
R2479 a_15180_41600.n148 a_15180_41600.t61 109.174
R2480 a_15180_41600.n147 a_15180_41600.t60 109.174
R2481 a_15180_41600.n124 a_15180_41600.t59 109.174
R2482 a_15180_41600.n143 a_15180_41600.t58 109.174
R2483 a_15180_41600.n142 a_15180_41600.t57 109.174
R2484 a_15180_41600.n141 a_15180_41600.t56 109.174
R2485 a_15180_41600.n126 a_15180_41600.t55 109.174
R2486 a_15180_41600.n137 a_15180_41600.t54 109.174
R2487 a_15180_41600.n136 a_15180_41600.t53 109.174
R2488 a_15180_41600.n135 a_15180_41600.t52 109.174
R2489 a_15180_41600.n128 a_15180_41600.t51 109.174
R2490 a_15180_41600.n131 a_15180_41600.t50 109.174
R2491 a_15180_41600.n130 a_15180_41600.t49 109.174
R2492 a_15180_41600.n85 a_15180_41600.t101 109.174
R2493 a_15180_41600.n86 a_15180_41600.t102 109.174
R2494 a_15180_41600.n37 a_15180_41600.t118 109.174
R2495 a_15180_41600.n38 a_15180_41600.t117 109.174
R2496 a_15180_41600.n39 a_15180_41600.t116 109.174
R2497 a_15180_41600.n40 a_15180_41600.t115 109.174
R2498 a_15180_41600.n41 a_15180_41600.t114 109.174
R2499 a_15180_41600.n42 a_15180_41600.t113 109.174
R2500 a_15180_41600.n43 a_15180_41600.t112 109.174
R2501 a_15180_41600.n44 a_15180_41600.t111 109.174
R2502 a_15180_41600.n45 a_15180_41600.t110 109.174
R2503 a_15180_41600.n46 a_15180_41600.t109 109.174
R2504 a_15180_41600.n47 a_15180_41600.t108 109.174
R2505 a_15180_41600.n48 a_15180_41600.t107 109.174
R2506 a_15180_41600.n49 a_15180_41600.t106 109.174
R2507 a_15180_41600.n50 a_15180_41600.t105 109.174
R2508 a_15180_41600.n51 a_15180_41600.t104 109.174
R2509 a_15180_41600.n52 a_15180_41600.t103 109.174
R2510 a_15180_41600.n84 a_15180_41600.t100 109.174
R2511 a_15180_41600.n53 a_15180_41600.t99 109.174
R2512 a_15180_41600.n80 a_15180_41600.t98 109.174
R2513 a_15180_41600.n79 a_15180_41600.t97 109.174
R2514 a_15180_41600.n78 a_15180_41600.t96 109.174
R2515 a_15180_41600.n55 a_15180_41600.t95 109.174
R2516 a_15180_41600.n74 a_15180_41600.t94 109.174
R2517 a_15180_41600.n73 a_15180_41600.t93 109.174
R2518 a_15180_41600.n72 a_15180_41600.t92 109.174
R2519 a_15180_41600.n57 a_15180_41600.t91 109.174
R2520 a_15180_41600.n68 a_15180_41600.t90 109.174
R2521 a_15180_41600.n67 a_15180_41600.t89 109.174
R2522 a_15180_41600.n66 a_15180_41600.t88 109.174
R2523 a_15180_41600.n59 a_15180_41600.t87 109.174
R2524 a_15180_41600.n62 a_15180_41600.t86 109.174
R2525 a_15180_41600.n61 a_15180_41600.t85 109.174
R2526 a_15180_41600.n154 a_15180_41600.n89 18.4942
R2527 a_15180_41600.n156 a_15180_41600.n155 18.4942
R2528 a_15180_41600.n107 a_15180_41600.n104 18.4942
R2529 a_15180_41600.n108 a_15180_41600.n103 18.4942
R2530 a_15180_41600.n109 a_15180_41600.n102 18.4942
R2531 a_15180_41600.n110 a_15180_41600.n101 18.4942
R2532 a_15180_41600.n111 a_15180_41600.n100 18.4942
R2533 a_15180_41600.n112 a_15180_41600.n99 18.4942
R2534 a_15180_41600.n113 a_15180_41600.n98 18.4942
R2535 a_15180_41600.n114 a_15180_41600.n97 18.4942
R2536 a_15180_41600.n115 a_15180_41600.n96 18.4942
R2537 a_15180_41600.n116 a_15180_41600.n95 18.4942
R2538 a_15180_41600.n117 a_15180_41600.n94 18.4942
R2539 a_15180_41600.n118 a_15180_41600.n93 18.4942
R2540 a_15180_41600.n119 a_15180_41600.n92 18.4942
R2541 a_15180_41600.n120 a_15180_41600.n91 18.4942
R2542 a_15180_41600.n121 a_15180_41600.n90 18.4942
R2543 a_15180_41600.n153 a_15180_41600.n152 18.4942
R2544 a_15180_41600.n151 a_15180_41600.n122 18.4942
R2545 a_15180_41600.n150 a_15180_41600.n149 18.4942
R2546 a_15180_41600.n148 a_15180_41600.n123 18.4942
R2547 a_15180_41600.n147 a_15180_41600.n146 18.4942
R2548 a_15180_41600.n145 a_15180_41600.n124 18.4942
R2549 a_15180_41600.n144 a_15180_41600.n143 18.4942
R2550 a_15180_41600.n142 a_15180_41600.n125 18.4942
R2551 a_15180_41600.n141 a_15180_41600.n140 18.4942
R2552 a_15180_41600.n139 a_15180_41600.n126 18.4942
R2553 a_15180_41600.n138 a_15180_41600.n137 18.4942
R2554 a_15180_41600.n136 a_15180_41600.n127 18.4942
R2555 a_15180_41600.n135 a_15180_41600.n134 18.4942
R2556 a_15180_41600.n133 a_15180_41600.n128 18.4942
R2557 a_15180_41600.n132 a_15180_41600.n131 18.4942
R2558 a_15180_41600.n85 a_15180_41600.n20 18.4942
R2559 a_15180_41600.n87 a_15180_41600.n86 18.4942
R2560 a_15180_41600.n38 a_15180_41600.n35 18.4942
R2561 a_15180_41600.n39 a_15180_41600.n34 18.4942
R2562 a_15180_41600.n40 a_15180_41600.n33 18.4942
R2563 a_15180_41600.n41 a_15180_41600.n32 18.4942
R2564 a_15180_41600.n42 a_15180_41600.n31 18.4942
R2565 a_15180_41600.n43 a_15180_41600.n30 18.4942
R2566 a_15180_41600.n44 a_15180_41600.n29 18.4942
R2567 a_15180_41600.n45 a_15180_41600.n28 18.4942
R2568 a_15180_41600.n46 a_15180_41600.n27 18.4942
R2569 a_15180_41600.n47 a_15180_41600.n26 18.4942
R2570 a_15180_41600.n48 a_15180_41600.n25 18.4942
R2571 a_15180_41600.n49 a_15180_41600.n24 18.4942
R2572 a_15180_41600.n50 a_15180_41600.n23 18.4942
R2573 a_15180_41600.n51 a_15180_41600.n22 18.4942
R2574 a_15180_41600.n52 a_15180_41600.n21 18.4942
R2575 a_15180_41600.n84 a_15180_41600.n83 18.4942
R2576 a_15180_41600.n82 a_15180_41600.n53 18.4942
R2577 a_15180_41600.n81 a_15180_41600.n80 18.4942
R2578 a_15180_41600.n79 a_15180_41600.n54 18.4942
R2579 a_15180_41600.n78 a_15180_41600.n77 18.4942
R2580 a_15180_41600.n76 a_15180_41600.n55 18.4942
R2581 a_15180_41600.n75 a_15180_41600.n74 18.4942
R2582 a_15180_41600.n73 a_15180_41600.n56 18.4942
R2583 a_15180_41600.n72 a_15180_41600.n71 18.4942
R2584 a_15180_41600.n70 a_15180_41600.n57 18.4942
R2585 a_15180_41600.n69 a_15180_41600.n68 18.4942
R2586 a_15180_41600.n67 a_15180_41600.n58 18.4942
R2587 a_15180_41600.n66 a_15180_41600.n65 18.4942
R2588 a_15180_41600.n64 a_15180_41600.n59 18.4942
R2589 a_15180_41600.n63 a_15180_41600.n62 18.4942
R2590 a_15180_41600.n182 a_15180_41600.n158 18.2054
R2591 a_15180_41600.n154 a_15180_41600.n153 11.6805
R2592 a_15180_41600.n155 a_15180_41600.n154 11.6805
R2593 a_15180_41600.n107 a_15180_41600.n106 11.6805
R2594 a_15180_41600.n108 a_15180_41600.n107 11.6805
R2595 a_15180_41600.n109 a_15180_41600.n108 11.6805
R2596 a_15180_41600.n110 a_15180_41600.n109 11.6805
R2597 a_15180_41600.n111 a_15180_41600.n110 11.6805
R2598 a_15180_41600.n112 a_15180_41600.n111 11.6805
R2599 a_15180_41600.n113 a_15180_41600.n112 11.6805
R2600 a_15180_41600.n114 a_15180_41600.n113 11.6805
R2601 a_15180_41600.n115 a_15180_41600.n114 11.6805
R2602 a_15180_41600.n116 a_15180_41600.n115 11.6805
R2603 a_15180_41600.n117 a_15180_41600.n116 11.6805
R2604 a_15180_41600.n118 a_15180_41600.n117 11.6805
R2605 a_15180_41600.n119 a_15180_41600.n118 11.6805
R2606 a_15180_41600.n120 a_15180_41600.n119 11.6805
R2607 a_15180_41600.n121 a_15180_41600.n120 11.6805
R2608 a_15180_41600.n155 a_15180_41600.n121 11.6805
R2609 a_15180_41600.n153 a_15180_41600.n122 11.6805
R2610 a_15180_41600.n149 a_15180_41600.n122 11.6805
R2611 a_15180_41600.n149 a_15180_41600.n148 11.6805
R2612 a_15180_41600.n148 a_15180_41600.n147 11.6805
R2613 a_15180_41600.n147 a_15180_41600.n124 11.6805
R2614 a_15180_41600.n143 a_15180_41600.n124 11.6805
R2615 a_15180_41600.n143 a_15180_41600.n142 11.6805
R2616 a_15180_41600.n142 a_15180_41600.n141 11.6805
R2617 a_15180_41600.n141 a_15180_41600.n126 11.6805
R2618 a_15180_41600.n137 a_15180_41600.n126 11.6805
R2619 a_15180_41600.n137 a_15180_41600.n136 11.6805
R2620 a_15180_41600.n136 a_15180_41600.n135 11.6805
R2621 a_15180_41600.n135 a_15180_41600.n128 11.6805
R2622 a_15180_41600.n131 a_15180_41600.n128 11.6805
R2623 a_15180_41600.n131 a_15180_41600.n130 11.6805
R2624 a_15180_41600.n85 a_15180_41600.n84 11.6805
R2625 a_15180_41600.n86 a_15180_41600.n85 11.6805
R2626 a_15180_41600.n38 a_15180_41600.n37 11.6805
R2627 a_15180_41600.n39 a_15180_41600.n38 11.6805
R2628 a_15180_41600.n40 a_15180_41600.n39 11.6805
R2629 a_15180_41600.n41 a_15180_41600.n40 11.6805
R2630 a_15180_41600.n42 a_15180_41600.n41 11.6805
R2631 a_15180_41600.n43 a_15180_41600.n42 11.6805
R2632 a_15180_41600.n44 a_15180_41600.n43 11.6805
R2633 a_15180_41600.n45 a_15180_41600.n44 11.6805
R2634 a_15180_41600.n46 a_15180_41600.n45 11.6805
R2635 a_15180_41600.n47 a_15180_41600.n46 11.6805
R2636 a_15180_41600.n48 a_15180_41600.n47 11.6805
R2637 a_15180_41600.n49 a_15180_41600.n48 11.6805
R2638 a_15180_41600.n50 a_15180_41600.n49 11.6805
R2639 a_15180_41600.n51 a_15180_41600.n50 11.6805
R2640 a_15180_41600.n52 a_15180_41600.n51 11.6805
R2641 a_15180_41600.n86 a_15180_41600.n52 11.6805
R2642 a_15180_41600.n84 a_15180_41600.n53 11.6805
R2643 a_15180_41600.n80 a_15180_41600.n53 11.6805
R2644 a_15180_41600.n80 a_15180_41600.n79 11.6805
R2645 a_15180_41600.n79 a_15180_41600.n78 11.6805
R2646 a_15180_41600.n78 a_15180_41600.n55 11.6805
R2647 a_15180_41600.n74 a_15180_41600.n55 11.6805
R2648 a_15180_41600.n74 a_15180_41600.n73 11.6805
R2649 a_15180_41600.n73 a_15180_41600.n72 11.6805
R2650 a_15180_41600.n72 a_15180_41600.n57 11.6805
R2651 a_15180_41600.n68 a_15180_41600.n57 11.6805
R2652 a_15180_41600.n68 a_15180_41600.n67 11.6805
R2653 a_15180_41600.n67 a_15180_41600.n66 11.6805
R2654 a_15180_41600.n66 a_15180_41600.n59 11.6805
R2655 a_15180_41600.n62 a_15180_41600.n59 11.6805
R2656 a_15180_41600.n62 a_15180_41600.n61 11.6805
R2657 a_15180_41600.n158 a_15180_41600.n88 10.688
R2658 a_15180_41600.n158 a_15180_41600.n157 9.24157
R2659 a_15180_41600.n132 a_15180_41600.n129 7.17687
R2660 a_15180_41600.n105 a_15180_41600.n104 7.17687
R2661 a_15180_41600.n63 a_15180_41600.n60 7.17687
R2662 a_15180_41600.n36 a_15180_41600.n35 7.17687
R2663 a_15180_41600.n183 a_15180_41600.n182 6.5392
R2664 a_15180_41600.n160 a_15180_41600.t21 5.7796
R2665 a_15180_41600.n1 a_15180_41600.t43 5.73764
R2666 a_15180_41600.n181 a_15180_41600.t42 5.59012
R2667 a_15180_41600.n183 a_15180_41600.t30 5.54817
R2668 a_15180_41600.n160 a_15180_41600.n159 5.38537
R2669 a_15180_41600.n162 a_15180_41600.n161 5.38537
R2670 a_15180_41600.n164 a_15180_41600.n163 5.38537
R2671 a_15180_41600.n166 a_15180_41600.n165 5.38537
R2672 a_15180_41600.n168 a_15180_41600.n167 5.38537
R2673 a_15180_41600.n170 a_15180_41600.n169 5.38537
R2674 a_15180_41600.n172 a_15180_41600.n171 5.38537
R2675 a_15180_41600.n174 a_15180_41600.n173 5.38537
R2676 a_15180_41600.n176 a_15180_41600.n175 5.38537
R2677 a_15180_41600.n178 a_15180_41600.n177 5.38537
R2678 a_15180_41600.n180 a_15180_41600.n179 5.38537
R2679 a_15180_41600.n185 a_15180_41600.n184 5.32067
R2680 a_15180_41600.n1 a_15180_41600.n0 5.32067
R2681 a_15180_41600.n3 a_15180_41600.n2 5.32067
R2682 a_15180_41600.n5 a_15180_41600.n4 5.32067
R2683 a_15180_41600.n7 a_15180_41600.n6 5.32067
R2684 a_15180_41600.n9 a_15180_41600.n8 5.32067
R2685 a_15180_41600.n11 a_15180_41600.n10 5.32067
R2686 a_15180_41600.n13 a_15180_41600.n12 5.32067
R2687 a_15180_41600.n15 a_15180_41600.n14 5.32067
R2688 a_15180_41600.n17 a_15180_41600.n16 5.32067
R2689 a_15180_41600.n19 a_15180_41600.n18 5.32067
R2690 a_15180_41600.n182 a_15180_41600.n181 4.61063
R2691 a_15180_41600.n106 a_15180_41600.n105 4.42851
R2692 a_15180_41600.n130 a_15180_41600.n129 4.42851
R2693 a_15180_41600.n37 a_15180_41600.n36 4.42851
R2694 a_15180_41600.n61 a_15180_41600.n60 4.42851
R2695 a_15180_41600.t0 a_15180_41600.n185 0.228
R2696 a_15180_41600.n185 a_15180_41600.t33 0.228
R2697 a_15180_41600.n0 a_15180_41600.t39 0.228
R2698 a_15180_41600.n0 a_15180_41600.t38 0.228
R2699 a_15180_41600.n2 a_15180_41600.t35 0.228
R2700 a_15180_41600.n2 a_15180_41600.t34 0.228
R2701 a_15180_41600.n4 a_15180_41600.t32 0.228
R2702 a_15180_41600.n4 a_15180_41600.t31 0.228
R2703 a_15180_41600.n6 a_15180_41600.t45 0.228
R2704 a_15180_41600.n6 a_15180_41600.t44 0.228
R2705 a_15180_41600.n8 a_15180_41600.t37 0.228
R2706 a_15180_41600.n8 a_15180_41600.t36 0.228
R2707 a_15180_41600.n10 a_15180_41600.t25 0.228
R2708 a_15180_41600.n10 a_15180_41600.t24 0.228
R2709 a_15180_41600.n12 a_15180_41600.t23 0.228
R2710 a_15180_41600.n12 a_15180_41600.t22 0.228
R2711 a_15180_41600.n14 a_15180_41600.t8 0.228
R2712 a_15180_41600.n14 a_15180_41600.t7 0.228
R2713 a_15180_41600.n16 a_15180_41600.t12 0.228
R2714 a_15180_41600.n16 a_15180_41600.t11 0.228
R2715 a_15180_41600.n18 a_15180_41600.t16 0.228
R2716 a_15180_41600.n18 a_15180_41600.t15 0.228
R2717 a_15180_41600.n159 a_15180_41600.t6 0.20525
R2718 a_15180_41600.n159 a_15180_41600.t5 0.20525
R2719 a_15180_41600.n161 a_15180_41600.t29 0.20525
R2720 a_15180_41600.n161 a_15180_41600.t28 0.20525
R2721 a_15180_41600.n163 a_15180_41600.t10 0.20525
R2722 a_15180_41600.n163 a_15180_41600.t9 0.20525
R2723 a_15180_41600.n165 a_15180_41600.t14 0.20525
R2724 a_15180_41600.n165 a_15180_41600.t13 0.20525
R2725 a_15180_41600.n167 a_15180_41600.t20 0.20525
R2726 a_15180_41600.n167 a_15180_41600.t19 0.20525
R2727 a_15180_41600.n169 a_15180_41600.t4 0.20525
R2728 a_15180_41600.n169 a_15180_41600.t3 0.20525
R2729 a_15180_41600.n171 a_15180_41600.t41 0.20525
R2730 a_15180_41600.n171 a_15180_41600.t40 0.20525
R2731 a_15180_41600.n173 a_15180_41600.t47 0.20525
R2732 a_15180_41600.n173 a_15180_41600.t46 0.20525
R2733 a_15180_41600.n175 a_15180_41600.t27 0.20525
R2734 a_15180_41600.n175 a_15180_41600.t26 0.20525
R2735 a_15180_41600.n177 a_15180_41600.t18 0.20525
R2736 a_15180_41600.n177 a_15180_41600.t17 0.20525
R2737 a_15180_41600.n179 a_15180_41600.t2 0.20525
R2738 a_15180_41600.n179 a_15180_41600.t1 0.20525
R2739 a_15180_41600.n184 a_15180_41600.n183 0.189974
R2740 a_15180_41600.n184 a_15180_41600.n19 0.189974
R2741 a_15180_41600.n19 a_15180_41600.n17 0.189974
R2742 a_15180_41600.n17 a_15180_41600.n15 0.189974
R2743 a_15180_41600.n15 a_15180_41600.n13 0.189974
R2744 a_15180_41600.n13 a_15180_41600.n11 0.189974
R2745 a_15180_41600.n11 a_15180_41600.n9 0.189974
R2746 a_15180_41600.n9 a_15180_41600.n7 0.189974
R2747 a_15180_41600.n7 a_15180_41600.n5 0.189974
R2748 a_15180_41600.n5 a_15180_41600.n3 0.189974
R2749 a_15180_41600.n3 a_15180_41600.n1 0.189974
R2750 a_15180_41600.n181 a_15180_41600.n180 0.189974
R2751 a_15180_41600.n180 a_15180_41600.n178 0.189974
R2752 a_15180_41600.n178 a_15180_41600.n176 0.189974
R2753 a_15180_41600.n176 a_15180_41600.n174 0.189974
R2754 a_15180_41600.n174 a_15180_41600.n172 0.189974
R2755 a_15180_41600.n172 a_15180_41600.n170 0.189974
R2756 a_15180_41600.n170 a_15180_41600.n168 0.189974
R2757 a_15180_41600.n168 a_15180_41600.n166 0.189974
R2758 a_15180_41600.n166 a_15180_41600.n164 0.189974
R2759 a_15180_41600.n164 a_15180_41600.n162 0.189974
R2760 a_15180_41600.n162 a_15180_41600.n160 0.189974
R2761 a_15180_41600.n152 a_15180_41600.n89 0.1205
R2762 a_15180_41600.n152 a_15180_41600.n151 0.1205
R2763 a_15180_41600.n151 a_15180_41600.n150 0.1205
R2764 a_15180_41600.n150 a_15180_41600.n123 0.1205
R2765 a_15180_41600.n146 a_15180_41600.n123 0.1205
R2766 a_15180_41600.n146 a_15180_41600.n145 0.1205
R2767 a_15180_41600.n145 a_15180_41600.n144 0.1205
R2768 a_15180_41600.n144 a_15180_41600.n125 0.1205
R2769 a_15180_41600.n140 a_15180_41600.n125 0.1205
R2770 a_15180_41600.n140 a_15180_41600.n139 0.1205
R2771 a_15180_41600.n139 a_15180_41600.n138 0.1205
R2772 a_15180_41600.n138 a_15180_41600.n127 0.1205
R2773 a_15180_41600.n134 a_15180_41600.n127 0.1205
R2774 a_15180_41600.n134 a_15180_41600.n133 0.1205
R2775 a_15180_41600.n133 a_15180_41600.n132 0.1205
R2776 a_15180_41600.n104 a_15180_41600.n103 0.1205
R2777 a_15180_41600.n103 a_15180_41600.n102 0.1205
R2778 a_15180_41600.n102 a_15180_41600.n101 0.1205
R2779 a_15180_41600.n101 a_15180_41600.n100 0.1205
R2780 a_15180_41600.n100 a_15180_41600.n99 0.1205
R2781 a_15180_41600.n99 a_15180_41600.n98 0.1205
R2782 a_15180_41600.n98 a_15180_41600.n97 0.1205
R2783 a_15180_41600.n97 a_15180_41600.n96 0.1205
R2784 a_15180_41600.n96 a_15180_41600.n95 0.1205
R2785 a_15180_41600.n95 a_15180_41600.n94 0.1205
R2786 a_15180_41600.n94 a_15180_41600.n93 0.1205
R2787 a_15180_41600.n93 a_15180_41600.n92 0.1205
R2788 a_15180_41600.n92 a_15180_41600.n91 0.1205
R2789 a_15180_41600.n91 a_15180_41600.n90 0.1205
R2790 a_15180_41600.n156 a_15180_41600.n90 0.1205
R2791 a_15180_41600.n83 a_15180_41600.n20 0.1205
R2792 a_15180_41600.n83 a_15180_41600.n82 0.1205
R2793 a_15180_41600.n82 a_15180_41600.n81 0.1205
R2794 a_15180_41600.n81 a_15180_41600.n54 0.1205
R2795 a_15180_41600.n77 a_15180_41600.n54 0.1205
R2796 a_15180_41600.n77 a_15180_41600.n76 0.1205
R2797 a_15180_41600.n76 a_15180_41600.n75 0.1205
R2798 a_15180_41600.n75 a_15180_41600.n56 0.1205
R2799 a_15180_41600.n71 a_15180_41600.n56 0.1205
R2800 a_15180_41600.n71 a_15180_41600.n70 0.1205
R2801 a_15180_41600.n70 a_15180_41600.n69 0.1205
R2802 a_15180_41600.n69 a_15180_41600.n58 0.1205
R2803 a_15180_41600.n65 a_15180_41600.n58 0.1205
R2804 a_15180_41600.n65 a_15180_41600.n64 0.1205
R2805 a_15180_41600.n64 a_15180_41600.n63 0.1205
R2806 a_15180_41600.n35 a_15180_41600.n34 0.1205
R2807 a_15180_41600.n34 a_15180_41600.n33 0.1205
R2808 a_15180_41600.n33 a_15180_41600.n32 0.1205
R2809 a_15180_41600.n32 a_15180_41600.n31 0.1205
R2810 a_15180_41600.n31 a_15180_41600.n30 0.1205
R2811 a_15180_41600.n30 a_15180_41600.n29 0.1205
R2812 a_15180_41600.n29 a_15180_41600.n28 0.1205
R2813 a_15180_41600.n28 a_15180_41600.n27 0.1205
R2814 a_15180_41600.n27 a_15180_41600.n26 0.1205
R2815 a_15180_41600.n26 a_15180_41600.n25 0.1205
R2816 a_15180_41600.n25 a_15180_41600.n24 0.1205
R2817 a_15180_41600.n24 a_15180_41600.n23 0.1205
R2818 a_15180_41600.n23 a_15180_41600.n22 0.1205
R2819 a_15180_41600.n22 a_15180_41600.n21 0.1205
R2820 a_15180_41600.n87 a_15180_41600.n21 0.1205
R2821 a_15180_41600.n157 a_15180_41600.n89 0.0485
R2822 a_15180_41600.n157 a_15180_41600.n156 0.0485
R2823 a_15180_41600.n88 a_15180_41600.n20 0.0485
R2824 a_15180_41600.n88 a_15180_41600.n87 0.0485
R2825 a_6924_41600.n62 a_6924_41600.t39 113.632
R2826 a_6924_41600.n78 a_6924_41600.t16 113.632
R2827 a_6924_41600.n17 a_6924_41600.t63 113.632
R2828 a_6924_41600.n33 a_6924_41600.t40 113.632
R2829 a_6924_41600.n93 a_6924_41600.t27 109.174
R2830 a_6924_41600.n94 a_6924_41600.t28 109.174
R2831 a_6924_41600.n63 a_6924_41600.t38 109.174
R2832 a_6924_41600.n64 a_6924_41600.t37 109.174
R2833 a_6924_41600.n65 a_6924_41600.t36 109.174
R2834 a_6924_41600.n66 a_6924_41600.t35 109.174
R2835 a_6924_41600.n67 a_6924_41600.t34 109.174
R2836 a_6924_41600.n68 a_6924_41600.t33 109.174
R2837 a_6924_41600.n69 a_6924_41600.t32 109.174
R2838 a_6924_41600.n70 a_6924_41600.t31 109.174
R2839 a_6924_41600.n71 a_6924_41600.t30 109.174
R2840 a_6924_41600.n72 a_6924_41600.t29 109.174
R2841 a_6924_41600.n92 a_6924_41600.t26 109.174
R2842 a_6924_41600.n73 a_6924_41600.t25 109.174
R2843 a_6924_41600.n88 a_6924_41600.t24 109.174
R2844 a_6924_41600.n87 a_6924_41600.t23 109.174
R2845 a_6924_41600.n86 a_6924_41600.t22 109.174
R2846 a_6924_41600.n75 a_6924_41600.t21 109.174
R2847 a_6924_41600.n82 a_6924_41600.t20 109.174
R2848 a_6924_41600.n81 a_6924_41600.t19 109.174
R2849 a_6924_41600.n80 a_6924_41600.t18 109.174
R2850 a_6924_41600.n77 a_6924_41600.t17 109.174
R2851 a_6924_41600.n48 a_6924_41600.t51 109.174
R2852 a_6924_41600.n49 a_6924_41600.t52 109.174
R2853 a_6924_41600.n18 a_6924_41600.t62 109.174
R2854 a_6924_41600.n19 a_6924_41600.t61 109.174
R2855 a_6924_41600.n20 a_6924_41600.t60 109.174
R2856 a_6924_41600.n21 a_6924_41600.t59 109.174
R2857 a_6924_41600.n22 a_6924_41600.t58 109.174
R2858 a_6924_41600.n23 a_6924_41600.t57 109.174
R2859 a_6924_41600.n24 a_6924_41600.t56 109.174
R2860 a_6924_41600.n25 a_6924_41600.t55 109.174
R2861 a_6924_41600.n26 a_6924_41600.t54 109.174
R2862 a_6924_41600.n27 a_6924_41600.t53 109.174
R2863 a_6924_41600.n47 a_6924_41600.t50 109.174
R2864 a_6924_41600.n28 a_6924_41600.t49 109.174
R2865 a_6924_41600.n43 a_6924_41600.t48 109.174
R2866 a_6924_41600.n42 a_6924_41600.t47 109.174
R2867 a_6924_41600.n41 a_6924_41600.t46 109.174
R2868 a_6924_41600.n30 a_6924_41600.t45 109.174
R2869 a_6924_41600.n37 a_6924_41600.t44 109.174
R2870 a_6924_41600.n36 a_6924_41600.t43 109.174
R2871 a_6924_41600.n35 a_6924_41600.t42 109.174
R2872 a_6924_41600.n32 a_6924_41600.t41 109.174
R2873 a_6924_41600.n98 a_6924_41600.n97 19.4712
R2874 a_6924_41600.n93 a_6924_41600.n52 18.4942
R2875 a_6924_41600.n95 a_6924_41600.n94 18.4942
R2876 a_6924_41600.n64 a_6924_41600.n61 18.4942
R2877 a_6924_41600.n65 a_6924_41600.n60 18.4942
R2878 a_6924_41600.n66 a_6924_41600.n59 18.4942
R2879 a_6924_41600.n67 a_6924_41600.n58 18.4942
R2880 a_6924_41600.n68 a_6924_41600.n57 18.4942
R2881 a_6924_41600.n69 a_6924_41600.n56 18.4942
R2882 a_6924_41600.n70 a_6924_41600.n55 18.4942
R2883 a_6924_41600.n71 a_6924_41600.n54 18.4942
R2884 a_6924_41600.n72 a_6924_41600.n53 18.4942
R2885 a_6924_41600.n92 a_6924_41600.n91 18.4942
R2886 a_6924_41600.n90 a_6924_41600.n73 18.4942
R2887 a_6924_41600.n89 a_6924_41600.n88 18.4942
R2888 a_6924_41600.n87 a_6924_41600.n74 18.4942
R2889 a_6924_41600.n86 a_6924_41600.n85 18.4942
R2890 a_6924_41600.n84 a_6924_41600.n75 18.4942
R2891 a_6924_41600.n83 a_6924_41600.n82 18.4942
R2892 a_6924_41600.n81 a_6924_41600.n76 18.4942
R2893 a_6924_41600.n80 a_6924_41600.n79 18.4942
R2894 a_6924_41600.n48 a_6924_41600.n7 18.4942
R2895 a_6924_41600.n50 a_6924_41600.n49 18.4942
R2896 a_6924_41600.n19 a_6924_41600.n16 18.4942
R2897 a_6924_41600.n20 a_6924_41600.n15 18.4942
R2898 a_6924_41600.n21 a_6924_41600.n14 18.4942
R2899 a_6924_41600.n22 a_6924_41600.n13 18.4942
R2900 a_6924_41600.n23 a_6924_41600.n12 18.4942
R2901 a_6924_41600.n24 a_6924_41600.n11 18.4942
R2902 a_6924_41600.n25 a_6924_41600.n10 18.4942
R2903 a_6924_41600.n26 a_6924_41600.n9 18.4942
R2904 a_6924_41600.n27 a_6924_41600.n8 18.4942
R2905 a_6924_41600.n47 a_6924_41600.n46 18.4942
R2906 a_6924_41600.n45 a_6924_41600.n28 18.4942
R2907 a_6924_41600.n44 a_6924_41600.n43 18.4942
R2908 a_6924_41600.n42 a_6924_41600.n29 18.4942
R2909 a_6924_41600.n41 a_6924_41600.n40 18.4942
R2910 a_6924_41600.n39 a_6924_41600.n30 18.4942
R2911 a_6924_41600.n38 a_6924_41600.n37 18.4942
R2912 a_6924_41600.n36 a_6924_41600.n31 18.4942
R2913 a_6924_41600.n35 a_6924_41600.n34 18.4942
R2914 a_6924_41600.n93 a_6924_41600.n92 11.6805
R2915 a_6924_41600.n94 a_6924_41600.n93 11.6805
R2916 a_6924_41600.n64 a_6924_41600.n63 11.6805
R2917 a_6924_41600.n65 a_6924_41600.n64 11.6805
R2918 a_6924_41600.n66 a_6924_41600.n65 11.6805
R2919 a_6924_41600.n67 a_6924_41600.n66 11.6805
R2920 a_6924_41600.n68 a_6924_41600.n67 11.6805
R2921 a_6924_41600.n69 a_6924_41600.n68 11.6805
R2922 a_6924_41600.n70 a_6924_41600.n69 11.6805
R2923 a_6924_41600.n71 a_6924_41600.n70 11.6805
R2924 a_6924_41600.n72 a_6924_41600.n71 11.6805
R2925 a_6924_41600.n94 a_6924_41600.n72 11.6805
R2926 a_6924_41600.n92 a_6924_41600.n73 11.6805
R2927 a_6924_41600.n88 a_6924_41600.n73 11.6805
R2928 a_6924_41600.n88 a_6924_41600.n87 11.6805
R2929 a_6924_41600.n87 a_6924_41600.n86 11.6805
R2930 a_6924_41600.n86 a_6924_41600.n75 11.6805
R2931 a_6924_41600.n82 a_6924_41600.n75 11.6805
R2932 a_6924_41600.n82 a_6924_41600.n81 11.6805
R2933 a_6924_41600.n81 a_6924_41600.n80 11.6805
R2934 a_6924_41600.n80 a_6924_41600.n77 11.6805
R2935 a_6924_41600.n48 a_6924_41600.n47 11.6805
R2936 a_6924_41600.n49 a_6924_41600.n48 11.6805
R2937 a_6924_41600.n19 a_6924_41600.n18 11.6805
R2938 a_6924_41600.n20 a_6924_41600.n19 11.6805
R2939 a_6924_41600.n21 a_6924_41600.n20 11.6805
R2940 a_6924_41600.n22 a_6924_41600.n21 11.6805
R2941 a_6924_41600.n23 a_6924_41600.n22 11.6805
R2942 a_6924_41600.n24 a_6924_41600.n23 11.6805
R2943 a_6924_41600.n25 a_6924_41600.n24 11.6805
R2944 a_6924_41600.n26 a_6924_41600.n25 11.6805
R2945 a_6924_41600.n27 a_6924_41600.n26 11.6805
R2946 a_6924_41600.n49 a_6924_41600.n27 11.6805
R2947 a_6924_41600.n47 a_6924_41600.n28 11.6805
R2948 a_6924_41600.n43 a_6924_41600.n28 11.6805
R2949 a_6924_41600.n43 a_6924_41600.n42 11.6805
R2950 a_6924_41600.n42 a_6924_41600.n41 11.6805
R2951 a_6924_41600.n41 a_6924_41600.n30 11.6805
R2952 a_6924_41600.n37 a_6924_41600.n30 11.6805
R2953 a_6924_41600.n37 a_6924_41600.n36 11.6805
R2954 a_6924_41600.n36 a_6924_41600.n35 11.6805
R2955 a_6924_41600.n35 a_6924_41600.n32 11.6805
R2956 a_6924_41600.n97 a_6924_41600.n51 10.013
R2957 a_6924_41600.n97 a_6924_41600.n96 9.91657
R2958 a_6924_41600.n79 a_6924_41600.n78 7.17687
R2959 a_6924_41600.n62 a_6924_41600.n61 7.17687
R2960 a_6924_41600.n34 a_6924_41600.n33 7.17687
R2961 a_6924_41600.n17 a_6924_41600.n16 7.17687
R2962 a_6924_41600.n98 a_6924_41600.n6 6.5392
R2963 a_6924_41600.t7 a_6924_41600.n105 5.7796
R2964 a_6924_41600.n1 a_6924_41600.t15 5.73764
R2965 a_6924_41600.n99 a_6924_41600.t0 5.59012
R2966 a_6924_41600.n6 a_6924_41600.t8 5.54817
R2967 a_6924_41600.n105 a_6924_41600.n104 5.38537
R2968 a_6924_41600.n103 a_6924_41600.n102 5.38537
R2969 a_6924_41600.n101 a_6924_41600.n100 5.38537
R2970 a_6924_41600.n1 a_6924_41600.n0 5.32067
R2971 a_6924_41600.n3 a_6924_41600.n2 5.32067
R2972 a_6924_41600.n5 a_6924_41600.n4 5.32067
R2973 a_6924_41600.n99 a_6924_41600.n98 4.61063
R2974 a_6924_41600.n63 a_6924_41600.n62 4.42851
R2975 a_6924_41600.n78 a_6924_41600.n77 4.42851
R2976 a_6924_41600.n18 a_6924_41600.n17 4.42851
R2977 a_6924_41600.n33 a_6924_41600.n32 4.42851
R2978 a_6924_41600.n0 a_6924_41600.t13 0.228
R2979 a_6924_41600.n0 a_6924_41600.t14 0.228
R2980 a_6924_41600.n2 a_6924_41600.t11 0.228
R2981 a_6924_41600.n2 a_6924_41600.t12 0.228
R2982 a_6924_41600.n4 a_6924_41600.t9 0.228
R2983 a_6924_41600.n4 a_6924_41600.t10 0.228
R2984 a_6924_41600.n104 a_6924_41600.t5 0.20525
R2985 a_6924_41600.n104 a_6924_41600.t6 0.20525
R2986 a_6924_41600.n102 a_6924_41600.t3 0.20525
R2987 a_6924_41600.n102 a_6924_41600.t4 0.20525
R2988 a_6924_41600.n100 a_6924_41600.t1 0.20525
R2989 a_6924_41600.n100 a_6924_41600.t2 0.20525
R2990 a_6924_41600.n101 a_6924_41600.n99 0.189974
R2991 a_6924_41600.n103 a_6924_41600.n101 0.189974
R2992 a_6924_41600.n105 a_6924_41600.n103 0.189974
R2993 a_6924_41600.n6 a_6924_41600.n5 0.189974
R2994 a_6924_41600.n5 a_6924_41600.n3 0.189974
R2995 a_6924_41600.n3 a_6924_41600.n1 0.189974
R2996 a_6924_41600.n91 a_6924_41600.n52 0.1205
R2997 a_6924_41600.n91 a_6924_41600.n90 0.1205
R2998 a_6924_41600.n90 a_6924_41600.n89 0.1205
R2999 a_6924_41600.n89 a_6924_41600.n74 0.1205
R3000 a_6924_41600.n85 a_6924_41600.n74 0.1205
R3001 a_6924_41600.n85 a_6924_41600.n84 0.1205
R3002 a_6924_41600.n84 a_6924_41600.n83 0.1205
R3003 a_6924_41600.n83 a_6924_41600.n76 0.1205
R3004 a_6924_41600.n79 a_6924_41600.n76 0.1205
R3005 a_6924_41600.n61 a_6924_41600.n60 0.1205
R3006 a_6924_41600.n60 a_6924_41600.n59 0.1205
R3007 a_6924_41600.n59 a_6924_41600.n58 0.1205
R3008 a_6924_41600.n58 a_6924_41600.n57 0.1205
R3009 a_6924_41600.n57 a_6924_41600.n56 0.1205
R3010 a_6924_41600.n56 a_6924_41600.n55 0.1205
R3011 a_6924_41600.n55 a_6924_41600.n54 0.1205
R3012 a_6924_41600.n54 a_6924_41600.n53 0.1205
R3013 a_6924_41600.n95 a_6924_41600.n53 0.1205
R3014 a_6924_41600.n46 a_6924_41600.n7 0.1205
R3015 a_6924_41600.n46 a_6924_41600.n45 0.1205
R3016 a_6924_41600.n45 a_6924_41600.n44 0.1205
R3017 a_6924_41600.n44 a_6924_41600.n29 0.1205
R3018 a_6924_41600.n40 a_6924_41600.n29 0.1205
R3019 a_6924_41600.n40 a_6924_41600.n39 0.1205
R3020 a_6924_41600.n39 a_6924_41600.n38 0.1205
R3021 a_6924_41600.n38 a_6924_41600.n31 0.1205
R3022 a_6924_41600.n34 a_6924_41600.n31 0.1205
R3023 a_6924_41600.n16 a_6924_41600.n15 0.1205
R3024 a_6924_41600.n15 a_6924_41600.n14 0.1205
R3025 a_6924_41600.n14 a_6924_41600.n13 0.1205
R3026 a_6924_41600.n13 a_6924_41600.n12 0.1205
R3027 a_6924_41600.n12 a_6924_41600.n11 0.1205
R3028 a_6924_41600.n11 a_6924_41600.n10 0.1205
R3029 a_6924_41600.n10 a_6924_41600.n9 0.1205
R3030 a_6924_41600.n9 a_6924_41600.n8 0.1205
R3031 a_6924_41600.n50 a_6924_41600.n8 0.1205
R3032 a_6924_41600.n96 a_6924_41600.n52 0.0485
R3033 a_6924_41600.n96 a_6924_41600.n95 0.0485
R3034 a_6924_41600.n51 a_6924_41600.n7 0.0485
R3035 a_6924_41600.n51 a_6924_41600.n50 0.0485
R3036 a_4812_41600.n18 a_4812_41600.t15 113.632
R3037 a_4812_41600.n22 a_4812_41600.t8 113.632
R3038 a_4812_41600.n5 a_4812_41600.t23 113.632
R3039 a_4812_41600.n9 a_4812_41600.t16 113.632
R3040 a_4812_41600.n25 a_4812_41600.t11 109.174
R3041 a_4812_41600.n26 a_4812_41600.t12 109.174
R3042 a_4812_41600.n19 a_4812_41600.t14 109.174
R3043 a_4812_41600.n20 a_4812_41600.t13 109.174
R3044 a_4812_41600.n24 a_4812_41600.t10 109.174
R3045 a_4812_41600.n21 a_4812_41600.t9 109.174
R3046 a_4812_41600.n12 a_4812_41600.t19 109.174
R3047 a_4812_41600.n13 a_4812_41600.t20 109.174
R3048 a_4812_41600.n6 a_4812_41600.t22 109.174
R3049 a_4812_41600.n7 a_4812_41600.t21 109.174
R3050 a_4812_41600.n11 a_4812_41600.t18 109.174
R3051 a_4812_41600.n8 a_4812_41600.t17 109.174
R3052 a_4812_41600.n25 a_4812_41600.n16 18.4942
R3053 a_4812_41600.n27 a_4812_41600.n26 18.4942
R3054 a_4812_41600.n20 a_4812_41600.n17 18.4942
R3055 a_4812_41600.n24 a_4812_41600.n23 18.4942
R3056 a_4812_41600.n12 a_4812_41600.n3 18.4942
R3057 a_4812_41600.n14 a_4812_41600.n13 18.4942
R3058 a_4812_41600.n7 a_4812_41600.n4 18.4942
R3059 a_4812_41600.n11 a_4812_41600.n10 18.4942
R3060 a_4812_41600.n30 a_4812_41600.n29 17.9305
R3061 a_4812_41600.n25 a_4812_41600.n24 11.6805
R3062 a_4812_41600.n26 a_4812_41600.n25 11.6805
R3063 a_4812_41600.n20 a_4812_41600.n19 11.6805
R3064 a_4812_41600.n26 a_4812_41600.n20 11.6805
R3065 a_4812_41600.n24 a_4812_41600.n21 11.6805
R3066 a_4812_41600.n12 a_4812_41600.n11 11.6805
R3067 a_4812_41600.n13 a_4812_41600.n12 11.6805
R3068 a_4812_41600.n7 a_4812_41600.n6 11.6805
R3069 a_4812_41600.n13 a_4812_41600.n7 11.6805
R3070 a_4812_41600.n11 a_4812_41600.n8 11.6805
R3071 a_4812_41600.n29 a_4812_41600.n15 10.3505
R3072 a_4812_41600.n29 a_4812_41600.n28 9.57907
R3073 a_4812_41600.n23 a_4812_41600.n22 7.17687
R3074 a_4812_41600.n18 a_4812_41600.n17 7.17687
R3075 a_4812_41600.n10 a_4812_41600.n9 7.17687
R3076 a_4812_41600.n5 a_4812_41600.n4 7.17687
R3077 a_4812_41600.n30 a_4812_41600.n2 6.5392
R3078 a_4812_41600.t3 a_4812_41600.n33 5.7796
R3079 a_4812_41600.n1 a_4812_41600.t7 5.73764
R3080 a_4812_41600.n31 a_4812_41600.t0 5.59012
R3081 a_4812_41600.n2 a_4812_41600.t4 5.54817
R3082 a_4812_41600.n33 a_4812_41600.n32 5.38537
R3083 a_4812_41600.n1 a_4812_41600.n0 5.32067
R3084 a_4812_41600.n31 a_4812_41600.n30 4.61063
R3085 a_4812_41600.n19 a_4812_41600.n18 4.42851
R3086 a_4812_41600.n22 a_4812_41600.n21 4.42851
R3087 a_4812_41600.n6 a_4812_41600.n5 4.42851
R3088 a_4812_41600.n9 a_4812_41600.n8 4.42851
R3089 a_4812_41600.n0 a_4812_41600.t5 0.228
R3090 a_4812_41600.n0 a_4812_41600.t6 0.228
R3091 a_4812_41600.n32 a_4812_41600.t1 0.20525
R3092 a_4812_41600.n32 a_4812_41600.t2 0.20525
R3093 a_4812_41600.n33 a_4812_41600.n31 0.189974
R3094 a_4812_41600.n2 a_4812_41600.n1 0.189974
R3095 a_4812_41600.n23 a_4812_41600.n16 0.1205
R3096 a_4812_41600.n27 a_4812_41600.n17 0.1205
R3097 a_4812_41600.n10 a_4812_41600.n3 0.1205
R3098 a_4812_41600.n14 a_4812_41600.n4 0.1205
R3099 a_4812_41600.n28 a_4812_41600.n16 0.0485
R3100 a_4812_41600.n28 a_4812_41600.n27 0.0485
R3101 a_4812_41600.n15 a_4812_41600.n3 0.0485
R3102 a_4812_41600.n15 a_4812_41600.n14 0.0485
R3103 a_2700_41600.n18 a_2700_41600.t15 113.632
R3104 a_2700_41600.n22 a_2700_41600.t8 113.632
R3105 a_2700_41600.n5 a_2700_41600.t23 113.632
R3106 a_2700_41600.n9 a_2700_41600.t16 113.632
R3107 a_2700_41600.n25 a_2700_41600.t11 109.174
R3108 a_2700_41600.n26 a_2700_41600.t12 109.174
R3109 a_2700_41600.n19 a_2700_41600.t14 109.174
R3110 a_2700_41600.n20 a_2700_41600.t13 109.174
R3111 a_2700_41600.n24 a_2700_41600.t10 109.174
R3112 a_2700_41600.n21 a_2700_41600.t9 109.174
R3113 a_2700_41600.n12 a_2700_41600.t19 109.174
R3114 a_2700_41600.n13 a_2700_41600.t20 109.174
R3115 a_2700_41600.n6 a_2700_41600.t22 109.174
R3116 a_2700_41600.n7 a_2700_41600.t21 109.174
R3117 a_2700_41600.n11 a_2700_41600.t18 109.174
R3118 a_2700_41600.n8 a_2700_41600.t17 109.174
R3119 a_2700_41600.n25 a_2700_41600.n16 18.4942
R3120 a_2700_41600.n27 a_2700_41600.n26 18.4942
R3121 a_2700_41600.n20 a_2700_41600.n17 18.4942
R3122 a_2700_41600.n24 a_2700_41600.n23 18.4942
R3123 a_2700_41600.n12 a_2700_41600.n3 18.4942
R3124 a_2700_41600.n14 a_2700_41600.n13 18.4942
R3125 a_2700_41600.n7 a_2700_41600.n4 18.4942
R3126 a_2700_41600.n11 a_2700_41600.n10 18.4942
R3127 a_2700_41600.n30 a_2700_41600.n29 17.6419
R3128 a_2700_41600.n25 a_2700_41600.n24 11.6805
R3129 a_2700_41600.n26 a_2700_41600.n25 11.6805
R3130 a_2700_41600.n20 a_2700_41600.n19 11.6805
R3131 a_2700_41600.n26 a_2700_41600.n20 11.6805
R3132 a_2700_41600.n24 a_2700_41600.n21 11.6805
R3133 a_2700_41600.n12 a_2700_41600.n11 11.6805
R3134 a_2700_41600.n13 a_2700_41600.n12 11.6805
R3135 a_2700_41600.n7 a_2700_41600.n6 11.6805
R3136 a_2700_41600.n13 a_2700_41600.n7 11.6805
R3137 a_2700_41600.n11 a_2700_41600.n8 11.6805
R3138 a_2700_41600.n29 a_2700_41600.n15 10.688
R3139 a_2700_41600.n29 a_2700_41600.n28 9.24157
R3140 a_2700_41600.n23 a_2700_41600.n22 7.17687
R3141 a_2700_41600.n18 a_2700_41600.n17 7.17687
R3142 a_2700_41600.n10 a_2700_41600.n9 7.17687
R3143 a_2700_41600.n5 a_2700_41600.n4 7.17687
R3144 a_2700_41600.n30 a_2700_41600.n2 6.5392
R3145 a_2700_41600.t3 a_2700_41600.n33 5.7796
R3146 a_2700_41600.n1 a_2700_41600.t7 5.73764
R3147 a_2700_41600.n31 a_2700_41600.t0 5.59012
R3148 a_2700_41600.n2 a_2700_41600.t4 5.54817
R3149 a_2700_41600.n33 a_2700_41600.n32 5.38537
R3150 a_2700_41600.n1 a_2700_41600.n0 5.32067
R3151 a_2700_41600.n31 a_2700_41600.n30 4.61063
R3152 a_2700_41600.n19 a_2700_41600.n18 4.42851
R3153 a_2700_41600.n22 a_2700_41600.n21 4.42851
R3154 a_2700_41600.n6 a_2700_41600.n5 4.42851
R3155 a_2700_41600.n9 a_2700_41600.n8 4.42851
R3156 a_2700_41600.n0 a_2700_41600.t5 0.228
R3157 a_2700_41600.n0 a_2700_41600.t6 0.228
R3158 a_2700_41600.n32 a_2700_41600.t1 0.20525
R3159 a_2700_41600.n32 a_2700_41600.t2 0.20525
R3160 a_2700_41600.n33 a_2700_41600.n31 0.189974
R3161 a_2700_41600.n2 a_2700_41600.n1 0.189974
R3162 a_2700_41600.n23 a_2700_41600.n16 0.1205
R3163 a_2700_41600.n27 a_2700_41600.n17 0.1205
R3164 a_2700_41600.n10 a_2700_41600.n3 0.1205
R3165 a_2700_41600.n14 a_2700_41600.n4 0.1205
R3166 a_2700_41600.n28 a_2700_41600.n16 0.0485
R3167 a_2700_41600.n28 a_2700_41600.n27 0.0485
R3168 a_2700_41600.n15 a_2700_41600.n3 0.0485
R3169 a_2700_41600.n15 a_2700_41600.n14 0.0485
C0 CLKP_HB VDD 4.51557f
C1 E_CAPTURE_CLKB E_CAPTURE_CLK 0.13895f
C2 E_CAPTURE_CLK VDD 11.2502f
C3 E_CAPTURE_CLKB VDD 11.3088f
C4 O_SENSE VDD 45.8831f
C5 O_CAPTURE_CLK VDD 11.2502f
C6 O_CAPTURE_CLKB VDD 11.3088f
C7 CLKN_H CLKN_HB 0.13381f
C8 CLKP_HB CLKP_H 0.13381f
C9 CLKP_H VDD 2.64315f
C10 O_CAPTURE_CLKB O_CAPTURE_CLK 0.13895f
C11 VDD CLKN_HB 4.51557f
C12 E_SENSE VDD 45.8831f
C13 CLKN_H VDD 2.64315f
C14 E_SENSE VSS 51.10835f
C15 E_CAPTURE_CLK VSS 13.22105f
C16 E_CAPTURE_CLKB VSS 11.56589f
C17 CLKP_H VSS 8.80759f
C18 CLKP_HB VSS 12.49212f
C19 O_SENSE VSS 51.10835f
C20 O_CAPTURE_CLK VSS 13.22105f
C21 O_CAPTURE_CLKB VSS 11.56589f
C22 CLKN_H VSS 8.80759f
C23 CLKN_HB VSS 12.96235f
C24 VDD VSS 2.72527p
C25 a_2700_41600.t7 VSS 0.79023f
C26 a_2700_41600.t6 VSS 0.18294f
C27 a_2700_41600.t5 VSS 0.18294f
C28 a_2700_41600.n0 VSS 0.58307f
C29 a_2700_41600.n1 VSS 0.32049f
C30 a_2700_41600.t4 VSS 0.785f
C31 a_2700_41600.n2 VSS 0.34615f
C32 a_2700_41600.n3 VSS 0.0539f
C33 a_2700_41600.n4 VSS 0.1862f
C34 a_2700_41600.n5 VSS 0.09204f
C35 a_2700_41600.n6 VSS 0.09865f
C36 a_2700_41600.n7 VSS 0.09865f
C37 a_2700_41600.n8 VSS 0.09865f
C38 a_2700_41600.n9 VSS 0.09204f
C39 a_2700_41600.n10 VSS 0.1862f
C40 a_2700_41600.n11 VSS 0.09865f
C41 a_2700_41600.n12 VSS 0.09865f
C42 a_2700_41600.n13 VSS 0.09865f
C43 a_2700_41600.n14 VSS 0.0539f
C44 a_2700_41600.n15 VSS 0.30259f
C45 a_2700_41600.n16 VSS 0.0539f
C46 a_2700_41600.n17 VSS 0.1862f
C47 a_2700_41600.n18 VSS 0.09204f
C48 a_2700_41600.n19 VSS 0.09865f
C49 a_2700_41600.n20 VSS 0.09865f
C50 a_2700_41600.n21 VSS 0.09865f
C51 a_2700_41600.n22 VSS 0.09204f
C52 a_2700_41600.n23 VSS 0.1862f
C53 a_2700_41600.n24 VSS 0.09865f
C54 a_2700_41600.n25 VSS 0.09865f
C55 a_2700_41600.n26 VSS 0.09865f
C56 a_2700_41600.n27 VSS 0.0539f
C57 a_2700_41600.n28 VSS 0.22663f
C58 a_2700_41600.n29 VSS 2.11369f
C59 a_2700_41600.n30 VSS 1.96684f
C60 a_2700_41600.t0 VSS 0.7836f
C61 a_2700_41600.n31 VSS 0.23471f
C62 a_2700_41600.t2 VSS 0.18294f
C63 a_2700_41600.t1 VSS 0.18294f
C64 a_2700_41600.n32 VSS 0.57877f
C65 a_2700_41600.n33 VSS 0.32618f
C66 a_2700_41600.t3 VSS 0.78884f
C67 a_4812_41600.t7 VSS 0.8116f
C68 a_4812_41600.t6 VSS 0.17696f
C69 a_4812_41600.t5 VSS 0.17696f
C70 a_4812_41600.n0 VSS 0.60959f
C71 a_4812_41600.n1 VSS 0.33507f
C72 a_4812_41600.t4 VSS 0.80613f
C73 a_4812_41600.n2 VSS 0.3619f
C74 a_4812_41600.n3 VSS 0.05635f
C75 a_4812_41600.n4 VSS 0.19467f
C76 a_4812_41600.n5 VSS 0.09622f
C77 a_4812_41600.n6 VSS 0.10314f
C78 a_4812_41600.n7 VSS 0.10314f
C79 a_4812_41600.n8 VSS 0.10314f
C80 a_4812_41600.n9 VSS 0.09622f
C81 a_4812_41600.n10 VSS 0.19467f
C82 a_4812_41600.n11 VSS 0.10314f
C83 a_4812_41600.n12 VSS 0.10314f
C84 a_4812_41600.n13 VSS 0.10314f
C85 a_4812_41600.n14 VSS 0.05635f
C86 a_4812_41600.n15 VSS 0.29267f
C87 a_4812_41600.n16 VSS 0.05635f
C88 a_4812_41600.n17 VSS 0.19467f
C89 a_4812_41600.n18 VSS 0.09622f
C90 a_4812_41600.n19 VSS 0.10314f
C91 a_4812_41600.n20 VSS 0.10314f
C92 a_4812_41600.n21 VSS 0.10314f
C93 a_4812_41600.n22 VSS 0.09622f
C94 a_4812_41600.n23 VSS 0.19467f
C95 a_4812_41600.n24 VSS 0.10314f
C96 a_4812_41600.n25 VSS 0.10314f
C97 a_4812_41600.n26 VSS 0.10314f
C98 a_4812_41600.n27 VSS 0.05635f
C99 a_4812_41600.n28 VSS 0.24991f
C100 a_4812_41600.n29 VSS 2.27959f
C101 a_4812_41600.n30 VSS 2.03081f
C102 a_4812_41600.t0 VSS 0.80467f
C103 a_4812_41600.n31 VSS 0.24539f
C104 a_4812_41600.t2 VSS 0.17696f
C105 a_4812_41600.t1 VSS 0.17696f
C106 a_4812_41600.n32 VSS 0.6051f
C107 a_4812_41600.n33 VSS 0.34102f
C108 a_4812_41600.t3 VSS 0.81015f
C109 a_6924_41600.t15 VSS 0.76158f
C110 a_6924_41600.t14 VSS 0.17845f
C111 a_6924_41600.t13 VSS 0.17845f
C112 a_6924_41600.n0 VSS 0.55982f
C113 a_6924_41600.n1 VSS 0.30772f
C114 a_6924_41600.t12 VSS 0.17845f
C115 a_6924_41600.t11 VSS 0.17845f
C116 a_6924_41600.n2 VSS 0.55982f
C117 a_6924_41600.n3 VSS 0.16064f
C118 a_6924_41600.t10 VSS 0.17845f
C119 a_6924_41600.t9 VSS 0.17845f
C120 a_6924_41600.n4 VSS 0.55982f
C121 a_6924_41600.n5 VSS 0.16064f
C122 a_6924_41600.t8 VSS 0.75656f
C123 a_6924_41600.n6 VSS 0.33235f
C124 a_6924_41600.n7 VSS 0.05175f
C125 a_6924_41600.n8 VSS 0.06142f
C126 a_6924_41600.n9 VSS 0.06142f
C127 a_6924_41600.n10 VSS 0.06142f
C128 a_6924_41600.n11 VSS 0.06142f
C129 a_6924_41600.n12 VSS 0.06142f
C130 a_6924_41600.n13 VSS 0.06142f
C131 a_6924_41600.n14 VSS 0.06142f
C132 a_6924_41600.n15 VSS 0.06142f
C133 a_6924_41600.n16 VSS 0.17878f
C134 a_6924_41600.n17 VSS 0.08837f
C135 a_6924_41600.n18 VSS 0.09472f
C136 a_6924_41600.n19 VSS 0.09472f
C137 a_6924_41600.n20 VSS 0.09472f
C138 a_6924_41600.n21 VSS 0.09472f
C139 a_6924_41600.n22 VSS 0.09472f
C140 a_6924_41600.n23 VSS 0.09472f
C141 a_6924_41600.n24 VSS 0.09472f
C142 a_6924_41600.n25 VSS 0.09472f
C143 a_6924_41600.n26 VSS 0.09472f
C144 a_6924_41600.n27 VSS 0.09472f
C145 a_6924_41600.n28 VSS 0.09472f
C146 a_6924_41600.n29 VSS 0.06142f
C147 a_6924_41600.n30 VSS 0.09472f
C148 a_6924_41600.n31 VSS 0.06142f
C149 a_6924_41600.n32 VSS 0.09472f
C150 a_6924_41600.n33 VSS 0.08837f
C151 a_6924_41600.n34 VSS 0.17878f
C152 a_6924_41600.n35 VSS 0.09472f
C153 a_6924_41600.n36 VSS 0.09472f
C154 a_6924_41600.n37 VSS 0.09472f
C155 a_6924_41600.n38 VSS 0.06142f
C156 a_6924_41600.n39 VSS 0.06142f
C157 a_6924_41600.n40 VSS 0.06142f
C158 a_6924_41600.n41 VSS 0.09472f
C159 a_6924_41600.n42 VSS 0.09472f
C160 a_6924_41600.n43 VSS 0.09472f
C161 a_6924_41600.n44 VSS 0.06142f
C162 a_6924_41600.n45 VSS 0.06142f
C163 a_6924_41600.n46 VSS 0.06142f
C164 a_6924_41600.n47 VSS 0.09472f
C165 a_6924_41600.n48 VSS 0.09472f
C166 a_6924_41600.n49 VSS 0.09472f
C167 a_6924_41600.n50 VSS 0.05175f
C168 a_6924_41600.n51 VSS 0.66009f
C169 a_6924_41600.n52 VSS 0.05175f
C170 a_6924_41600.n53 VSS 0.06142f
C171 a_6924_41600.n54 VSS 0.06142f
C172 a_6924_41600.n55 VSS 0.06142f
C173 a_6924_41600.n56 VSS 0.06142f
C174 a_6924_41600.n57 VSS 0.06142f
C175 a_6924_41600.n58 VSS 0.06142f
C176 a_6924_41600.n59 VSS 0.06142f
C177 a_6924_41600.n60 VSS 0.06142f
C178 a_6924_41600.n61 VSS 0.17878f
C179 a_6924_41600.n62 VSS 0.08837f
C180 a_6924_41600.n63 VSS 0.09472f
C181 a_6924_41600.n64 VSS 0.09472f
C182 a_6924_41600.n65 VSS 0.09472f
C183 a_6924_41600.n66 VSS 0.09472f
C184 a_6924_41600.n67 VSS 0.09472f
C185 a_6924_41600.n68 VSS 0.09472f
C186 a_6924_41600.n69 VSS 0.09472f
C187 a_6924_41600.n70 VSS 0.09472f
C188 a_6924_41600.n71 VSS 0.09472f
C189 a_6924_41600.n72 VSS 0.09472f
C190 a_6924_41600.n73 VSS 0.09472f
C191 a_6924_41600.n74 VSS 0.06142f
C192 a_6924_41600.n75 VSS 0.09472f
C193 a_6924_41600.n76 VSS 0.06142f
C194 a_6924_41600.n77 VSS 0.09472f
C195 a_6924_41600.n78 VSS 0.08837f
C196 a_6924_41600.n79 VSS 0.17878f
C197 a_6924_41600.n80 VSS 0.09472f
C198 a_6924_41600.n81 VSS 0.09472f
C199 a_6924_41600.n82 VSS 0.09472f
C200 a_6924_41600.n83 VSS 0.06142f
C201 a_6924_41600.n84 VSS 0.06142f
C202 a_6924_41600.n85 VSS 0.06142f
C203 a_6924_41600.n86 VSS 0.09472f
C204 a_6924_41600.n87 VSS 0.09472f
C205 a_6924_41600.n88 VSS 0.09472f
C206 a_6924_41600.n89 VSS 0.06142f
C207 a_6924_41600.n90 VSS 0.06142f
C208 a_6924_41600.n91 VSS 0.06142f
C209 a_6924_41600.n92 VSS 0.09472f
C210 a_6924_41600.n93 VSS 0.09472f
C211 a_6924_41600.n94 VSS 0.09472f
C212 a_6924_41600.n95 VSS 0.05175f
C213 a_6924_41600.n96 VSS 0.6519f
C214 a_6924_41600.n97 VSS 2.97932f
C215 a_6924_41600.n98 VSS 1.99322f
C216 a_6924_41600.t0 VSS 0.75521f
C217 a_6924_41600.n99 VSS 0.22535f
C218 a_6924_41600.t2 VSS 0.17845f
C219 a_6924_41600.t1 VSS 0.17845f
C220 a_6924_41600.n100 VSS 0.55569f
C221 a_6924_41600.n101 VSS 0.16476f
C222 a_6924_41600.t4 VSS 0.17845f
C223 a_6924_41600.t3 VSS 0.17845f
C224 a_6924_41600.n102 VSS 0.55569f
C225 a_6924_41600.n103 VSS 0.16476f
C226 a_6924_41600.t6 VSS 0.17845f
C227 a_6924_41600.t5 VSS 0.17845f
C228 a_6924_41600.n104 VSS 0.55569f
C229 a_6924_41600.n105 VSS 0.31318f
C230 a_6924_41600.t7 VSS 0.76025f
C231 a_15180_41600.t33 VSS 0.2099f
C232 a_15180_41600.t43 VSS 0.84626f
C233 a_15180_41600.t38 VSS 0.2099f
C234 a_15180_41600.t39 VSS 0.2099f
C235 a_15180_41600.n0 VSS 0.61064f
C236 a_15180_41600.n1 VSS 0.33565f
C237 a_15180_41600.t34 VSS 0.2099f
C238 a_15180_41600.t35 VSS 0.2099f
C239 a_15180_41600.n2 VSS 0.61064f
C240 a_15180_41600.n3 VSS 0.17522f
C241 a_15180_41600.t31 VSS 0.2099f
C242 a_15180_41600.t32 VSS 0.2099f
C243 a_15180_41600.n4 VSS 0.61064f
C244 a_15180_41600.n5 VSS 0.17522f
C245 a_15180_41600.t44 VSS 0.2099f
C246 a_15180_41600.t45 VSS 0.2099f
C247 a_15180_41600.n6 VSS 0.61064f
C248 a_15180_41600.n7 VSS 0.17522f
C249 a_15180_41600.t36 VSS 0.2099f
C250 a_15180_41600.t37 VSS 0.2099f
C251 a_15180_41600.n8 VSS 0.61064f
C252 a_15180_41600.n9 VSS 0.17522f
C253 a_15180_41600.t24 VSS 0.2099f
C254 a_15180_41600.t25 VSS 0.2099f
C255 a_15180_41600.n10 VSS 0.61064f
C256 a_15180_41600.n11 VSS 0.17522f
C257 a_15180_41600.t22 VSS 0.2099f
C258 a_15180_41600.t23 VSS 0.2099f
C259 a_15180_41600.n12 VSS 0.61064f
C260 a_15180_41600.n13 VSS 0.17522f
C261 a_15180_41600.t7 VSS 0.2099f
C262 a_15180_41600.t8 VSS 0.2099f
C263 a_15180_41600.n14 VSS 0.61064f
C264 a_15180_41600.n15 VSS 0.17522f
C265 a_15180_41600.t11 VSS 0.2099f
C266 a_15180_41600.t12 VSS 0.2099f
C267 a_15180_41600.n16 VSS 0.61064f
C268 a_15180_41600.n17 VSS 0.17522f
C269 a_15180_41600.t15 VSS 0.2099f
C270 a_15180_41600.t16 VSS 0.2099f
C271 a_15180_41600.n18 VSS 0.61064f
C272 a_15180_41600.n19 VSS 0.17522f
C273 a_15180_41600.n20 VSS 0.05645f
C274 a_15180_41600.n21 VSS 0.067f
C275 a_15180_41600.n22 VSS 0.067f
C276 a_15180_41600.n23 VSS 0.067f
C277 a_15180_41600.n24 VSS 0.067f
C278 a_15180_41600.n25 VSS 0.067f
C279 a_15180_41600.n26 VSS 0.067f
C280 a_15180_41600.n27 VSS 0.067f
C281 a_15180_41600.n28 VSS 0.067f
C282 a_15180_41600.n29 VSS 0.067f
C283 a_15180_41600.n30 VSS 0.067f
C284 a_15180_41600.n31 VSS 0.067f
C285 a_15180_41600.n32 VSS 0.067f
C286 a_15180_41600.n33 VSS 0.067f
C287 a_15180_41600.n34 VSS 0.067f
C288 a_15180_41600.n35 VSS 0.19501f
C289 a_15180_41600.n36 VSS 0.09639f
C290 a_15180_41600.n37 VSS 0.10332f
C291 a_15180_41600.n38 VSS 0.10332f
C292 a_15180_41600.n39 VSS 0.10332f
C293 a_15180_41600.n40 VSS 0.10332f
C294 a_15180_41600.n41 VSS 0.10332f
C295 a_15180_41600.n42 VSS 0.10332f
C296 a_15180_41600.n43 VSS 0.10332f
C297 a_15180_41600.n44 VSS 0.10332f
C298 a_15180_41600.n45 VSS 0.10332f
C299 a_15180_41600.n46 VSS 0.10332f
C300 a_15180_41600.n47 VSS 0.10332f
C301 a_15180_41600.n48 VSS 0.10332f
C302 a_15180_41600.n49 VSS 0.10332f
C303 a_15180_41600.n50 VSS 0.10332f
C304 a_15180_41600.n51 VSS 0.10332f
C305 a_15180_41600.n52 VSS 0.10332f
C306 a_15180_41600.n53 VSS 0.10332f
C307 a_15180_41600.n54 VSS 0.067f
C308 a_15180_41600.n55 VSS 0.10332f
C309 a_15180_41600.n56 VSS 0.067f
C310 a_15180_41600.n57 VSS 0.10332f
C311 a_15180_41600.n58 VSS 0.067f
C312 a_15180_41600.n59 VSS 0.10332f
C313 a_15180_41600.n60 VSS 0.09639f
C314 a_15180_41600.n61 VSS 0.10332f
C315 a_15180_41600.n62 VSS 0.10332f
C316 a_15180_41600.n63 VSS 0.19501f
C317 a_15180_41600.n64 VSS 0.067f
C318 a_15180_41600.n65 VSS 0.067f
C319 a_15180_41600.n66 VSS 0.10332f
C320 a_15180_41600.n67 VSS 0.10332f
C321 a_15180_41600.n68 VSS 0.10332f
C322 a_15180_41600.n69 VSS 0.067f
C323 a_15180_41600.n70 VSS 0.067f
C324 a_15180_41600.n71 VSS 0.067f
C325 a_15180_41600.n72 VSS 0.10332f
C326 a_15180_41600.n73 VSS 0.10332f
C327 a_15180_41600.n74 VSS 0.10332f
C328 a_15180_41600.n75 VSS 0.067f
C329 a_15180_41600.n76 VSS 0.067f
C330 a_15180_41600.n77 VSS 0.067f
C331 a_15180_41600.n78 VSS 0.10332f
C332 a_15180_41600.n79 VSS 0.10332f
C333 a_15180_41600.n80 VSS 0.10332f
C334 a_15180_41600.n81 VSS 0.067f
C335 a_15180_41600.n82 VSS 0.067f
C336 a_15180_41600.n83 VSS 0.067f
C337 a_15180_41600.n84 VSS 0.10332f
C338 a_15180_41600.n85 VSS 0.10332f
C339 a_15180_41600.n86 VSS 0.10332f
C340 a_15180_41600.n87 VSS 0.05645f
C341 a_15180_41600.n88 VSS 1.14068f
C342 a_15180_41600.n89 VSS 0.05645f
C343 a_15180_41600.n90 VSS 0.067f
C344 a_15180_41600.n91 VSS 0.067f
C345 a_15180_41600.n92 VSS 0.067f
C346 a_15180_41600.n93 VSS 0.067f
C347 a_15180_41600.n94 VSS 0.067f
C348 a_15180_41600.n95 VSS 0.067f
C349 a_15180_41600.n96 VSS 0.067f
C350 a_15180_41600.n97 VSS 0.067f
C351 a_15180_41600.n98 VSS 0.067f
C352 a_15180_41600.n99 VSS 0.067f
C353 a_15180_41600.n100 VSS 0.067f
C354 a_15180_41600.n101 VSS 0.067f
C355 a_15180_41600.n102 VSS 0.067f
C356 a_15180_41600.n103 VSS 0.067f
C357 a_15180_41600.n104 VSS 0.19501f
C358 a_15180_41600.n105 VSS 0.09639f
C359 a_15180_41600.n106 VSS 0.10332f
C360 a_15180_41600.n107 VSS 0.10332f
C361 a_15180_41600.n108 VSS 0.10332f
C362 a_15180_41600.n109 VSS 0.10332f
C363 a_15180_41600.n110 VSS 0.10332f
C364 a_15180_41600.n111 VSS 0.10332f
C365 a_15180_41600.n112 VSS 0.10332f
C366 a_15180_41600.n113 VSS 0.10332f
C367 a_15180_41600.n114 VSS 0.10332f
C368 a_15180_41600.n115 VSS 0.10332f
C369 a_15180_41600.n116 VSS 0.10332f
C370 a_15180_41600.n117 VSS 0.10332f
C371 a_15180_41600.n118 VSS 0.10332f
C372 a_15180_41600.n119 VSS 0.10332f
C373 a_15180_41600.n120 VSS 0.10332f
C374 a_15180_41600.n121 VSS 0.10332f
C375 a_15180_41600.n122 VSS 0.10332f
C376 a_15180_41600.n123 VSS 0.067f
C377 a_15180_41600.n124 VSS 0.10332f
C378 a_15180_41600.n125 VSS 0.067f
C379 a_15180_41600.n126 VSS 0.10332f
C380 a_15180_41600.n127 VSS 0.067f
C381 a_15180_41600.n128 VSS 0.10332f
C382 a_15180_41600.n129 VSS 0.09639f
C383 a_15180_41600.n130 VSS 0.10332f
C384 a_15180_41600.n131 VSS 0.10332f
C385 a_15180_41600.n132 VSS 0.19501f
C386 a_15180_41600.n133 VSS 0.067f
C387 a_15180_41600.n134 VSS 0.067f
C388 a_15180_41600.n135 VSS 0.10332f
C389 a_15180_41600.n136 VSS 0.10332f
C390 a_15180_41600.n137 VSS 0.10332f
C391 a_15180_41600.n138 VSS 0.067f
C392 a_15180_41600.n139 VSS 0.067f
C393 a_15180_41600.n140 VSS 0.067f
C394 a_15180_41600.n141 VSS 0.10332f
C395 a_15180_41600.n142 VSS 0.10332f
C396 a_15180_41600.n143 VSS 0.10332f
C397 a_15180_41600.n144 VSS 0.067f
C398 a_15180_41600.n145 VSS 0.067f
C399 a_15180_41600.n146 VSS 0.067f
C400 a_15180_41600.n147 VSS 0.10332f
C401 a_15180_41600.n148 VSS 0.10332f
C402 a_15180_41600.n149 VSS 0.10332f
C403 a_15180_41600.n150 VSS 0.067f
C404 a_15180_41600.n151 VSS 0.067f
C405 a_15180_41600.n152 VSS 0.067f
C406 a_15180_41600.n153 VSS 0.10332f
C407 a_15180_41600.n154 VSS 0.10332f
C408 a_15180_41600.n155 VSS 0.10332f
C409 a_15180_41600.n156 VSS 0.05645f
C410 a_15180_41600.n157 VSS 0.96736f
C411 a_15180_41600.n158 VSS 3.58277f
C412 a_15180_41600.t21 VSS 0.84481f
C413 a_15180_41600.t5 VSS 0.2099f
C414 a_15180_41600.t6 VSS 0.2099f
C415 a_15180_41600.n159 VSS 0.60614f
C416 a_15180_41600.n160 VSS 0.34161f
C417 a_15180_41600.t28 VSS 0.2099f
C418 a_15180_41600.t29 VSS 0.2099f
C419 a_15180_41600.n161 VSS 0.60614f
C420 a_15180_41600.n162 VSS 0.17972f
C421 a_15180_41600.t9 VSS 0.2099f
C422 a_15180_41600.t10 VSS 0.2099f
C423 a_15180_41600.n163 VSS 0.60614f
C424 a_15180_41600.n164 VSS 0.17972f
C425 a_15180_41600.t13 VSS 0.2099f
C426 a_15180_41600.t14 VSS 0.2099f
C427 a_15180_41600.n165 VSS 0.60614f
C428 a_15180_41600.n166 VSS 0.17972f
C429 a_15180_41600.t19 VSS 0.2099f
C430 a_15180_41600.t20 VSS 0.2099f
C431 a_15180_41600.n167 VSS 0.60614f
C432 a_15180_41600.n168 VSS 0.17972f
C433 a_15180_41600.t3 VSS 0.2099f
C434 a_15180_41600.t4 VSS 0.2099f
C435 a_15180_41600.n169 VSS 0.60614f
C436 a_15180_41600.n170 VSS 0.17972f
C437 a_15180_41600.t40 VSS 0.2099f
C438 a_15180_41600.t41 VSS 0.2099f
C439 a_15180_41600.n171 VSS 0.60614f
C440 a_15180_41600.n172 VSS 0.17972f
C441 a_15180_41600.t46 VSS 0.2099f
C442 a_15180_41600.t47 VSS 0.2099f
C443 a_15180_41600.n173 VSS 0.60614f
C444 a_15180_41600.n174 VSS 0.17972f
C445 a_15180_41600.t26 VSS 0.2099f
C446 a_15180_41600.t27 VSS 0.2099f
C447 a_15180_41600.n175 VSS 0.60614f
C448 a_15180_41600.n176 VSS 0.17972f
C449 a_15180_41600.t17 VSS 0.2099f
C450 a_15180_41600.t18 VSS 0.2099f
C451 a_15180_41600.n177 VSS 0.60614f
C452 a_15180_41600.n178 VSS 0.17972f
C453 a_15180_41600.t1 VSS 0.2099f
C454 a_15180_41600.t2 VSS 0.2099f
C455 a_15180_41600.n179 VSS 0.60614f
C456 a_15180_41600.n180 VSS 0.17972f
C457 a_15180_41600.t42 VSS 0.83932f
C458 a_15180_41600.n181 VSS 0.24581f
C459 a_15180_41600.n182 VSS 2.13305f
C460 a_15180_41600.t30 VSS 0.84078f
C461 a_15180_41600.n183 VSS 0.36252f
C462 a_15180_41600.n184 VSS 0.17522f
C463 a_15180_41600.n185 VSS 0.61064f
C464 a_15180_41600.t0 VSS 0.2099f
C465 a_2700_6400.t7 VSS 0.79129f
C466 a_2700_6400.t6 VSS 0.18399f
C467 a_2700_6400.t5 VSS 0.18399f
C468 a_2700_6400.n0 VSS 0.58307f
C469 a_2700_6400.n1 VSS 0.32049f
C470 a_2700_6400.t4 VSS 0.78606f
C471 a_2700_6400.n2 VSS 0.34615f
C472 a_2700_6400.n3 VSS 0.0539f
C473 a_2700_6400.n4 VSS 0.1862f
C474 a_2700_6400.n5 VSS 0.09204f
C475 a_2700_6400.n6 VSS 0.09865f
C476 a_2700_6400.n7 VSS 0.09865f
C477 a_2700_6400.n8 VSS 0.09865f
C478 a_2700_6400.n9 VSS 0.09204f
C479 a_2700_6400.n10 VSS 0.1862f
C480 a_2700_6400.n11 VSS 0.09865f
C481 a_2700_6400.n12 VSS 0.09865f
C482 a_2700_6400.n13 VSS 0.09865f
C483 a_2700_6400.n14 VSS 0.0539f
C484 a_2700_6400.n15 VSS 0.30259f
C485 a_2700_6400.n16 VSS 0.0539f
C486 a_2700_6400.n17 VSS 0.1862f
C487 a_2700_6400.n18 VSS 0.09204f
C488 a_2700_6400.n19 VSS 0.09865f
C489 a_2700_6400.n20 VSS 0.09865f
C490 a_2700_6400.n21 VSS 0.09865f
C491 a_2700_6400.n22 VSS 0.09204f
C492 a_2700_6400.n23 VSS 0.1862f
C493 a_2700_6400.n24 VSS 0.09865f
C494 a_2700_6400.n25 VSS 0.09865f
C495 a_2700_6400.n26 VSS 0.09865f
C496 a_2700_6400.n27 VSS 0.0539f
C497 a_2700_6400.n28 VSS 0.22663f
C498 a_2700_6400.n29 VSS 2.11369f
C499 a_2700_6400.n30 VSS 1.96684f
C500 a_2700_6400.t0 VSS 0.78466f
C501 a_2700_6400.n31 VSS 0.23471f
C502 a_2700_6400.t2 VSS 0.18399f
C503 a_2700_6400.t1 VSS 0.18399f
C504 a_2700_6400.n32 VSS 0.57877f
C505 a_2700_6400.n33 VSS 0.32618f
C506 a_2700_6400.t3 VSS 0.7899f
C507 a_4812_6400.t7 VSS 0.8116f
C508 a_4812_6400.t6 VSS 0.17696f
C509 a_4812_6400.t5 VSS 0.17696f
C510 a_4812_6400.n0 VSS 0.60959f
C511 a_4812_6400.n1 VSS 0.33507f
C512 a_4812_6400.t4 VSS 0.80613f
C513 a_4812_6400.n2 VSS 0.3619f
C514 a_4812_6400.n3 VSS 0.05635f
C515 a_4812_6400.n4 VSS 0.19467f
C516 a_4812_6400.n5 VSS 0.09622f
C517 a_4812_6400.n6 VSS 0.10314f
C518 a_4812_6400.n7 VSS 0.10314f
C519 a_4812_6400.n8 VSS 0.10314f
C520 a_4812_6400.n9 VSS 0.09622f
C521 a_4812_6400.n10 VSS 0.19467f
C522 a_4812_6400.n11 VSS 0.10314f
C523 a_4812_6400.n12 VSS 0.10314f
C524 a_4812_6400.n13 VSS 0.10314f
C525 a_4812_6400.n14 VSS 0.05635f
C526 a_4812_6400.n15 VSS 0.29267f
C527 a_4812_6400.n16 VSS 0.05635f
C528 a_4812_6400.n17 VSS 0.19467f
C529 a_4812_6400.n18 VSS 0.09622f
C530 a_4812_6400.n19 VSS 0.10314f
C531 a_4812_6400.n20 VSS 0.10314f
C532 a_4812_6400.n21 VSS 0.10314f
C533 a_4812_6400.n22 VSS 0.09622f
C534 a_4812_6400.n23 VSS 0.19467f
C535 a_4812_6400.n24 VSS 0.10314f
C536 a_4812_6400.n25 VSS 0.10314f
C537 a_4812_6400.n26 VSS 0.10314f
C538 a_4812_6400.n27 VSS 0.05635f
C539 a_4812_6400.n28 VSS 0.24991f
C540 a_4812_6400.n29 VSS 2.27959f
C541 a_4812_6400.n30 VSS 2.03081f
C542 a_4812_6400.t0 VSS 0.80467f
C543 a_4812_6400.n31 VSS 0.24539f
C544 a_4812_6400.t2 VSS 0.17696f
C545 a_4812_6400.t1 VSS 0.17696f
C546 a_4812_6400.n32 VSS 0.6051f
C547 a_4812_6400.n33 VSS 0.34102f
C548 a_4812_6400.t3 VSS 0.81015f
C549 a_6924_6400.t15 VSS 0.76264f
C550 a_6924_6400.t14 VSS 0.17949f
C551 a_6924_6400.t13 VSS 0.17949f
C552 a_6924_6400.n0 VSS 0.55982f
C553 a_6924_6400.n1 VSS 0.30772f
C554 a_6924_6400.t12 VSS 0.17949f
C555 a_6924_6400.t11 VSS 0.17949f
C556 a_6924_6400.n2 VSS 0.55982f
C557 a_6924_6400.n3 VSS 0.16064f
C558 a_6924_6400.t10 VSS 0.17949f
C559 a_6924_6400.t9 VSS 0.17949f
C560 a_6924_6400.n4 VSS 0.55982f
C561 a_6924_6400.n5 VSS 0.16064f
C562 a_6924_6400.t8 VSS 0.75762f
C563 a_6924_6400.n6 VSS 0.33235f
C564 a_6924_6400.n7 VSS 0.05175f
C565 a_6924_6400.n8 VSS 0.06142f
C566 a_6924_6400.n9 VSS 0.06142f
C567 a_6924_6400.n10 VSS 0.06142f
C568 a_6924_6400.n11 VSS 0.06142f
C569 a_6924_6400.n12 VSS 0.06142f
C570 a_6924_6400.n13 VSS 0.06142f
C571 a_6924_6400.n14 VSS 0.06142f
C572 a_6924_6400.n15 VSS 0.06142f
C573 a_6924_6400.n16 VSS 0.17878f
C574 a_6924_6400.n17 VSS 0.08837f
C575 a_6924_6400.n18 VSS 0.09472f
C576 a_6924_6400.n19 VSS 0.09472f
C577 a_6924_6400.n20 VSS 0.09472f
C578 a_6924_6400.n21 VSS 0.09472f
C579 a_6924_6400.n22 VSS 0.09472f
C580 a_6924_6400.n23 VSS 0.09472f
C581 a_6924_6400.n24 VSS 0.09472f
C582 a_6924_6400.n25 VSS 0.09472f
C583 a_6924_6400.n26 VSS 0.09472f
C584 a_6924_6400.n27 VSS 0.09472f
C585 a_6924_6400.n28 VSS 0.09472f
C586 a_6924_6400.n29 VSS 0.06142f
C587 a_6924_6400.n30 VSS 0.09472f
C588 a_6924_6400.n31 VSS 0.06142f
C589 a_6924_6400.n32 VSS 0.09472f
C590 a_6924_6400.n33 VSS 0.08837f
C591 a_6924_6400.n34 VSS 0.17878f
C592 a_6924_6400.n35 VSS 0.09472f
C593 a_6924_6400.n36 VSS 0.09472f
C594 a_6924_6400.n37 VSS 0.09472f
C595 a_6924_6400.n38 VSS 0.06142f
C596 a_6924_6400.n39 VSS 0.06142f
C597 a_6924_6400.n40 VSS 0.06142f
C598 a_6924_6400.n41 VSS 0.09472f
C599 a_6924_6400.n42 VSS 0.09472f
C600 a_6924_6400.n43 VSS 0.09472f
C601 a_6924_6400.n44 VSS 0.06142f
C602 a_6924_6400.n45 VSS 0.06142f
C603 a_6924_6400.n46 VSS 0.06142f
C604 a_6924_6400.n47 VSS 0.09472f
C605 a_6924_6400.n48 VSS 0.09472f
C606 a_6924_6400.n49 VSS 0.09472f
C607 a_6924_6400.n50 VSS 0.05175f
C608 a_6924_6400.n51 VSS 0.66009f
C609 a_6924_6400.n52 VSS 0.05175f
C610 a_6924_6400.n53 VSS 0.06142f
C611 a_6924_6400.n54 VSS 0.06142f
C612 a_6924_6400.n55 VSS 0.06142f
C613 a_6924_6400.n56 VSS 0.06142f
C614 a_6924_6400.n57 VSS 0.06142f
C615 a_6924_6400.n58 VSS 0.06142f
C616 a_6924_6400.n59 VSS 0.06142f
C617 a_6924_6400.n60 VSS 0.06142f
C618 a_6924_6400.n61 VSS 0.17878f
C619 a_6924_6400.n62 VSS 0.08837f
C620 a_6924_6400.n63 VSS 0.09472f
C621 a_6924_6400.n64 VSS 0.09472f
C622 a_6924_6400.n65 VSS 0.09472f
C623 a_6924_6400.n66 VSS 0.09472f
C624 a_6924_6400.n67 VSS 0.09472f
C625 a_6924_6400.n68 VSS 0.09472f
C626 a_6924_6400.n69 VSS 0.09472f
C627 a_6924_6400.n70 VSS 0.09472f
C628 a_6924_6400.n71 VSS 0.09472f
C629 a_6924_6400.n72 VSS 0.09472f
C630 a_6924_6400.n73 VSS 0.09472f
C631 a_6924_6400.n74 VSS 0.06142f
C632 a_6924_6400.n75 VSS 0.09472f
C633 a_6924_6400.n76 VSS 0.06142f
C634 a_6924_6400.n77 VSS 0.09472f
C635 a_6924_6400.n78 VSS 0.08837f
C636 a_6924_6400.n79 VSS 0.17878f
C637 a_6924_6400.n80 VSS 0.09472f
C638 a_6924_6400.n81 VSS 0.09472f
C639 a_6924_6400.n82 VSS 0.09472f
C640 a_6924_6400.n83 VSS 0.06142f
C641 a_6924_6400.n84 VSS 0.06142f
C642 a_6924_6400.n85 VSS 0.06142f
C643 a_6924_6400.n86 VSS 0.09472f
C644 a_6924_6400.n87 VSS 0.09472f
C645 a_6924_6400.n88 VSS 0.09472f
C646 a_6924_6400.n89 VSS 0.06142f
C647 a_6924_6400.n90 VSS 0.06142f
C648 a_6924_6400.n91 VSS 0.06142f
C649 a_6924_6400.n92 VSS 0.09472f
C650 a_6924_6400.n93 VSS 0.09472f
C651 a_6924_6400.n94 VSS 0.09472f
C652 a_6924_6400.n95 VSS 0.05175f
C653 a_6924_6400.n96 VSS 0.6519f
C654 a_6924_6400.n97 VSS 2.97932f
C655 a_6924_6400.n98 VSS 1.99322f
C656 a_6924_6400.t0 VSS 0.75628f
C657 a_6924_6400.n99 VSS 0.22535f
C658 a_6924_6400.t2 VSS 0.17949f
C659 a_6924_6400.t1 VSS 0.17949f
C660 a_6924_6400.n100 VSS 0.55569f
C661 a_6924_6400.n101 VSS 0.16476f
C662 a_6924_6400.t4 VSS 0.17949f
C663 a_6924_6400.t3 VSS 0.17949f
C664 a_6924_6400.n102 VSS 0.55569f
C665 a_6924_6400.n103 VSS 0.16476f
C666 a_6924_6400.t6 VSS 0.17949f
C667 a_6924_6400.t5 VSS 0.17949f
C668 a_6924_6400.n104 VSS 0.55569f
C669 a_6924_6400.n105 VSS 0.31318f
C670 a_6924_6400.t7 VSS 0.76131f
C671 a_15180_6400.t23 VSS 0.2099f
C672 a_15180_6400.t12 VSS 0.84481f
C673 a_15180_6400.t13 VSS 0.2099f
C674 a_15180_6400.t20 VSS 0.2099f
C675 a_15180_6400.n0 VSS 0.60614f
C676 a_15180_6400.n1 VSS 0.34161f
C677 a_15180_6400.t21 VSS 0.2099f
C678 a_15180_6400.t24 VSS 0.2099f
C679 a_15180_6400.n2 VSS 0.60614f
C680 a_15180_6400.n3 VSS 0.17972f
C681 a_15180_6400.t25 VSS 0.2099f
C682 a_15180_6400.t2 VSS 0.2099f
C683 a_15180_6400.n4 VSS 0.60614f
C684 a_15180_6400.n5 VSS 0.17972f
C685 a_15180_6400.t3 VSS 0.2099f
C686 a_15180_6400.t32 VSS 0.2099f
C687 a_15180_6400.n6 VSS 0.60614f
C688 a_15180_6400.n7 VSS 0.17972f
C689 a_15180_6400.t33 VSS 0.2099f
C690 a_15180_6400.t10 VSS 0.2099f
C691 a_15180_6400.n8 VSS 0.60614f
C692 a_15180_6400.n9 VSS 0.17972f
C693 a_15180_6400.t11 VSS 0.2099f
C694 a_15180_6400.t18 VSS 0.2099f
C695 a_15180_6400.n10 VSS 0.60614f
C696 a_15180_6400.n11 VSS 0.17972f
C697 a_15180_6400.t19 VSS 0.2099f
C698 a_15180_6400.t22 VSS 0.2099f
C699 a_15180_6400.n12 VSS 0.60614f
C700 a_15180_6400.n13 VSS 0.17972f
C701 a_15180_6400.t8 VSS 0.84626f
C702 a_15180_6400.t9 VSS 0.2099f
C703 a_15180_6400.t16 VSS 0.2099f
C704 a_15180_6400.n14 VSS 0.61064f
C705 a_15180_6400.n15 VSS 0.33565f
C706 a_15180_6400.t17 VSS 0.2099f
C707 a_15180_6400.t14 VSS 0.2099f
C708 a_15180_6400.n16 VSS 0.61064f
C709 a_15180_6400.n17 VSS 0.17522f
C710 a_15180_6400.t15 VSS 0.2099f
C711 a_15180_6400.t44 VSS 0.2099f
C712 a_15180_6400.n18 VSS 0.61064f
C713 a_15180_6400.n19 VSS 0.17522f
C714 a_15180_6400.t45 VSS 0.2099f
C715 a_15180_6400.t46 VSS 0.2099f
C716 a_15180_6400.n20 VSS 0.61064f
C717 a_15180_6400.n21 VSS 0.17522f
C718 a_15180_6400.t47 VSS 0.2099f
C719 a_15180_6400.t42 VSS 0.2099f
C720 a_15180_6400.n22 VSS 0.61064f
C721 a_15180_6400.n23 VSS 0.17522f
C722 a_15180_6400.t43 VSS 0.2099f
C723 a_15180_6400.t6 VSS 0.2099f
C724 a_15180_6400.n24 VSS 0.61064f
C725 a_15180_6400.n25 VSS 0.17522f
C726 a_15180_6400.t7 VSS 0.2099f
C727 a_15180_6400.t26 VSS 0.2099f
C728 a_15180_6400.n26 VSS 0.61064f
C729 a_15180_6400.n27 VSS 0.17522f
C730 a_15180_6400.t27 VSS 0.2099f
C731 a_15180_6400.t40 VSS 0.2099f
C732 a_15180_6400.n28 VSS 0.61064f
C733 a_15180_6400.n29 VSS 0.17522f
C734 a_15180_6400.t41 VSS 0.2099f
C735 a_15180_6400.t28 VSS 0.2099f
C736 a_15180_6400.n30 VSS 0.61064f
C737 a_15180_6400.n31 VSS 0.17522f
C738 a_15180_6400.t29 VSS 0.2099f
C739 a_15180_6400.t36 VSS 0.2099f
C740 a_15180_6400.n32 VSS 0.61064f
C741 a_15180_6400.n33 VSS 0.17522f
C742 a_15180_6400.t37 VSS 0.2099f
C743 a_15180_6400.t34 VSS 0.2099f
C744 a_15180_6400.n34 VSS 0.61064f
C745 a_15180_6400.n35 VSS 0.17522f
C746 a_15180_6400.t35 VSS 0.84078f
C747 a_15180_6400.n36 VSS 0.36252f
C748 a_15180_6400.n37 VSS 0.05645f
C749 a_15180_6400.n38 VSS 0.067f
C750 a_15180_6400.n39 VSS 0.067f
C751 a_15180_6400.n40 VSS 0.067f
C752 a_15180_6400.n41 VSS 0.067f
C753 a_15180_6400.n42 VSS 0.067f
C754 a_15180_6400.n43 VSS 0.067f
C755 a_15180_6400.n44 VSS 0.067f
C756 a_15180_6400.n45 VSS 0.067f
C757 a_15180_6400.n46 VSS 0.067f
C758 a_15180_6400.n47 VSS 0.067f
C759 a_15180_6400.n48 VSS 0.067f
C760 a_15180_6400.n49 VSS 0.067f
C761 a_15180_6400.n50 VSS 0.067f
C762 a_15180_6400.n51 VSS 0.067f
C763 a_15180_6400.n52 VSS 0.19501f
C764 a_15180_6400.n53 VSS 0.09639f
C765 a_15180_6400.n54 VSS 0.10332f
C766 a_15180_6400.n55 VSS 0.10332f
C767 a_15180_6400.n56 VSS 0.10332f
C768 a_15180_6400.n57 VSS 0.10332f
C769 a_15180_6400.n58 VSS 0.10332f
C770 a_15180_6400.n59 VSS 0.10332f
C771 a_15180_6400.n60 VSS 0.10332f
C772 a_15180_6400.n61 VSS 0.10332f
C773 a_15180_6400.n62 VSS 0.10332f
C774 a_15180_6400.n63 VSS 0.10332f
C775 a_15180_6400.n64 VSS 0.10332f
C776 a_15180_6400.n65 VSS 0.10332f
C777 a_15180_6400.n66 VSS 0.10332f
C778 a_15180_6400.n67 VSS 0.10332f
C779 a_15180_6400.n68 VSS 0.10332f
C780 a_15180_6400.n69 VSS 0.10332f
C781 a_15180_6400.n70 VSS 0.10332f
C782 a_15180_6400.n71 VSS 0.067f
C783 a_15180_6400.n72 VSS 0.10332f
C784 a_15180_6400.n73 VSS 0.067f
C785 a_15180_6400.n74 VSS 0.10332f
C786 a_15180_6400.n75 VSS 0.067f
C787 a_15180_6400.n76 VSS 0.10332f
C788 a_15180_6400.n77 VSS 0.09639f
C789 a_15180_6400.n78 VSS 0.10332f
C790 a_15180_6400.n79 VSS 0.10332f
C791 a_15180_6400.n80 VSS 0.19501f
C792 a_15180_6400.n81 VSS 0.067f
C793 a_15180_6400.n82 VSS 0.067f
C794 a_15180_6400.n83 VSS 0.10332f
C795 a_15180_6400.n84 VSS 0.10332f
C796 a_15180_6400.n85 VSS 0.10332f
C797 a_15180_6400.n86 VSS 0.067f
C798 a_15180_6400.n87 VSS 0.067f
C799 a_15180_6400.n88 VSS 0.067f
C800 a_15180_6400.n89 VSS 0.10332f
C801 a_15180_6400.n90 VSS 0.10332f
C802 a_15180_6400.n91 VSS 0.10332f
C803 a_15180_6400.n92 VSS 0.067f
C804 a_15180_6400.n93 VSS 0.067f
C805 a_15180_6400.n94 VSS 0.067f
C806 a_15180_6400.n95 VSS 0.10332f
C807 a_15180_6400.n96 VSS 0.10332f
C808 a_15180_6400.n97 VSS 0.10332f
C809 a_15180_6400.n98 VSS 0.067f
C810 a_15180_6400.n99 VSS 0.067f
C811 a_15180_6400.n100 VSS 0.067f
C812 a_15180_6400.n101 VSS 0.10332f
C813 a_15180_6400.n102 VSS 0.10332f
C814 a_15180_6400.n103 VSS 0.10332f
C815 a_15180_6400.n104 VSS 0.05645f
C816 a_15180_6400.n105 VSS 1.14068f
C817 a_15180_6400.n106 VSS 0.05645f
C818 a_15180_6400.n107 VSS 0.067f
C819 a_15180_6400.n108 VSS 0.067f
C820 a_15180_6400.n109 VSS 0.067f
C821 a_15180_6400.n110 VSS 0.067f
C822 a_15180_6400.n111 VSS 0.067f
C823 a_15180_6400.n112 VSS 0.067f
C824 a_15180_6400.n113 VSS 0.067f
C825 a_15180_6400.n114 VSS 0.067f
C826 a_15180_6400.n115 VSS 0.067f
C827 a_15180_6400.n116 VSS 0.067f
C828 a_15180_6400.n117 VSS 0.067f
C829 a_15180_6400.n118 VSS 0.067f
C830 a_15180_6400.n119 VSS 0.067f
C831 a_15180_6400.n120 VSS 0.067f
C832 a_15180_6400.n121 VSS 0.19501f
C833 a_15180_6400.n122 VSS 0.09639f
C834 a_15180_6400.n123 VSS 0.10332f
C835 a_15180_6400.n124 VSS 0.10332f
C836 a_15180_6400.n125 VSS 0.10332f
C837 a_15180_6400.n126 VSS 0.10332f
C838 a_15180_6400.n127 VSS 0.10332f
C839 a_15180_6400.n128 VSS 0.10332f
C840 a_15180_6400.n129 VSS 0.10332f
C841 a_15180_6400.n130 VSS 0.10332f
C842 a_15180_6400.n131 VSS 0.10332f
C843 a_15180_6400.n132 VSS 0.10332f
C844 a_15180_6400.n133 VSS 0.10332f
C845 a_15180_6400.n134 VSS 0.10332f
C846 a_15180_6400.n135 VSS 0.10332f
C847 a_15180_6400.n136 VSS 0.10332f
C848 a_15180_6400.n137 VSS 0.10332f
C849 a_15180_6400.n138 VSS 0.10332f
C850 a_15180_6400.n139 VSS 0.10332f
C851 a_15180_6400.n140 VSS 0.067f
C852 a_15180_6400.n141 VSS 0.10332f
C853 a_15180_6400.n142 VSS 0.067f
C854 a_15180_6400.n143 VSS 0.10332f
C855 a_15180_6400.n144 VSS 0.067f
C856 a_15180_6400.n145 VSS 0.10332f
C857 a_15180_6400.n146 VSS 0.09639f
C858 a_15180_6400.n147 VSS 0.10332f
C859 a_15180_6400.n148 VSS 0.10332f
C860 a_15180_6400.n149 VSS 0.19501f
C861 a_15180_6400.n150 VSS 0.067f
C862 a_15180_6400.n151 VSS 0.067f
C863 a_15180_6400.n152 VSS 0.10332f
C864 a_15180_6400.n153 VSS 0.10332f
C865 a_15180_6400.n154 VSS 0.10332f
C866 a_15180_6400.n155 VSS 0.067f
C867 a_15180_6400.n156 VSS 0.067f
C868 a_15180_6400.n157 VSS 0.067f
C869 a_15180_6400.n158 VSS 0.10332f
C870 a_15180_6400.n159 VSS 0.10332f
C871 a_15180_6400.n160 VSS 0.10332f
C872 a_15180_6400.n161 VSS 0.067f
C873 a_15180_6400.n162 VSS 0.067f
C874 a_15180_6400.n163 VSS 0.067f
C875 a_15180_6400.n164 VSS 0.10332f
C876 a_15180_6400.n165 VSS 0.10332f
C877 a_15180_6400.n166 VSS 0.10332f
C878 a_15180_6400.n167 VSS 0.067f
C879 a_15180_6400.n168 VSS 0.067f
C880 a_15180_6400.n169 VSS 0.067f
C881 a_15180_6400.n170 VSS 0.10332f
C882 a_15180_6400.n171 VSS 0.10332f
C883 a_15180_6400.n172 VSS 0.10332f
C884 a_15180_6400.n173 VSS 0.05645f
C885 a_15180_6400.n174 VSS 0.96736f
C886 a_15180_6400.n175 VSS 3.58277f
C887 a_15180_6400.n176 VSS 2.13305f
C888 a_15180_6400.t39 VSS 0.83932f
C889 a_15180_6400.n177 VSS 0.24581f
C890 a_15180_6400.t31 VSS 0.2099f
C891 a_15180_6400.t38 VSS 0.2099f
C892 a_15180_6400.n178 VSS 0.60614f
C893 a_15180_6400.n179 VSS 0.17972f
C894 a_15180_6400.t5 VSS 0.2099f
C895 a_15180_6400.t30 VSS 0.2099f
C896 a_15180_6400.n180 VSS 0.60614f
C897 a_15180_6400.n181 VSS 0.17972f
C898 a_15180_6400.t1 VSS 0.2099f
C899 a_15180_6400.t4 VSS 0.2099f
C900 a_15180_6400.n182 VSS 0.60614f
C901 a_15180_6400.n183 VSS 0.17972f
C902 a_15180_6400.n184 VSS 0.17972f
C903 a_15180_6400.n185 VSS 0.60614f
C904 a_15180_6400.t0 VSS 0.2099f
C905 VSS.t61 VSS 0.10028f
C906 VSS.t63 VSS 0.1022f
C907 VSS.t129 VSS 0.10028f
C908 VSS.t131 VSS 0.10028f
C909 VSS.t153 VSS 0.10028f
C910 VSS.t155 VSS 0.10028f
C911 VSS.t353 VSS 0.10028f
C912 VSS.t355 VSS 0.10028f
C913 VSS.t193 VSS 0.10028f
C914 VSS.t195 VSS 0.10028f
C915 VSS.t205 VSS 0.10028f
C916 VSS.t207 VSS 0.10028f
C917 VSS.t65 VSS 0.10028f
C918 VSS.t67 VSS 0.10028f
C919 VSS.t133 VSS 0.10028f
C920 VSS.t135 VSS 0.10028f
C921 VSS.t157 VSS 0.10028f
C922 VSS.t159 VSS 0.10028f
C923 VSS.t357 VSS 0.10028f
C924 VSS.t359 VSS 0.10028f
C925 VSS.t221 VSS 0.10028f
C926 VSS.t223 VSS 0.10028f
C927 VSS.t139 VSS 0.10028f
C928 VSS.t141 VSS 0.10028f
C929 VSS.t341 VSS 0.10028f
C930 VSS.t343 VSS 0.10028f
C931 VSS.t197 VSS 0.10028f
C932 VSS.t199 VSS 0.10028f
C933 VSS.t209 VSS 0.10028f
C934 VSS.t211 VSS 0.10028f
C935 VSS.t361 VSS 0.10028f
C936 VSS.t363 VSS 0.10028f
C937 VSS.t225 VSS 0.10028f
C938 VSS.t227 VSS 0.10028f
C939 VSS.t325 VSS 0.1022f
C940 VSS.t327 VSS 0.10028f
C941 VSS.t239 VSS 0.09193f
C942 VSS.t241 VSS 0.0937f
C943 VSS.t125 VSS 0.09193f
C944 VSS.t127 VSS 0.09193f
C945 VSS.t15 VSS 0.09193f
C946 VSS.t17 VSS 0.09193f
C947 VSS.t7 VSS 0.09193f
C948 VSS.t9 VSS 0.09193f
C949 VSS.t95 VSS 0.09193f
C950 VSS.t97 VSS 0.09193f
C951 VSS.t79 VSS 0.09193f
C952 VSS.t81 VSS 0.09193f
C953 VSS.t49 VSS 0.09193f
C954 VSS.t51 VSS 0.09193f
C955 VSS.t183 VSS 0.09193f
C956 VSS.t185 VSS 0.09193f
C957 VSS.t11 VSS 0.09193f
C958 VSS.t13 VSS 0.09193f
C959 VSS.t99 VSS 0.09193f
C960 VSS.t101 VSS 0.09193f
C961 VSS.t83 VSS 0.09193f
C962 VSS.t85 VSS 0.09193f
C963 VSS.t53 VSS 0.0937f
C964 VSS.t55 VSS 0.09193f
C965 VSS.t179 VSS 0.10011f
C966 VSS.t113 VSS 0.10203f
C967 VSS.t203 VSS 0.10011f
C968 VSS.t163 VSS 0.10011f
C969 VSS.t219 VSS 0.10011f
C970 VSS.t217 VSS 0.10011f
C971 VSS.t339 VSS 0.10203f
C972 VSS.t191 VSS 0.10011f
C973 VSS.t69 VSS 0.09575f
C974 VSS.t345 VSS 0.09759f
C975 VSS.t187 VSS 0.09575f
C976 VSS.t93 VSS 0.09575f
C977 VSS.t91 VSS 0.09575f
C978 VSS.t71 VSS 0.09575f
C979 VSS.t37 VSS 0.09759f
C980 VSS.t181 VSS 0.09575f
C981 VSS.t267 VSS 0.07134f
C982 VSS.t259 VSS 0.07271f
C983 VSS.t271 VSS 0.07134f
C984 VSS.t269 VSS 0.07134f
C985 VSS.t275 VSS 0.07134f
C986 VSS.t273 VSS 0.07134f
C987 VSS.t279 VSS 0.07271f
C988 VSS.t277 VSS 0.07134f
C989 VSS.t315 VSS 0.0592f
C990 VSS.t313 VSS 0.06033f
C991 VSS.t317 VSS 0.06033f
C992 VSS.t319 VSS 0.0592f
C993 VSS.t261 VSS 0.07134f
C994 VSS.t257 VSS 0.07271f
C995 VSS.t265 VSS 0.07271f
C996 VSS.t263 VSS 0.07134f
C997 VSS.t161 VSS 0.10028f
C998 VSS.t145 VSS 0.1022f
C999 VSS.t213 VSS 0.10028f
C1000 VSS.t347 VSS 0.10028f
C1001 VSS.t189 VSS 0.10028f
C1002 VSS.t331 VSS 0.10028f
C1003 VSS.t1 VSS 0.10028f
C1004 VSS.t73 VSS 0.10028f
C1005 VSS.t39 VSS 0.10028f
C1006 VSS.t201 VSS 0.10028f
C1007 VSS.t147 VSS 0.10028f
C1008 VSS.t115 VSS 0.10028f
C1009 VSS.t349 VSS 0.10028f
C1010 VSS.t165 VSS 0.10028f
C1011 VSS.t321 VSS 0.10028f
C1012 VSS.t215 VSS 0.10028f
C1013 VSS.t117 VSS 0.10028f
C1014 VSS.t41 VSS 0.10028f
C1015 VSS.t351 VSS 0.10028f
C1016 VSS.t149 VSS 0.10028f
C1017 VSS.t151 VSS 0.10028f
C1018 VSS.t333 VSS 0.10028f
C1019 VSS.t237 VSS 0.10028f
C1020 VSS.t249 VSS 0.10028f
C1021 VSS.t119 VSS 0.10028f
C1022 VSS.t43 VSS 0.10028f
C1023 VSS.t3 VSS 0.10028f
C1024 VSS.t75 VSS 0.10028f
C1025 VSS.t121 VSS 0.10028f
C1026 VSS.t45 VSS 0.10028f
C1027 VSS.t77 VSS 0.10028f
C1028 VSS.t243 VSS 0.10028f
C1029 VSS.t47 VSS 0.10028f
C1030 VSS.t5 VSS 0.10028f
C1031 VSS.t173 VSS 0.1022f
C1032 VSS.t123 VSS 0.10028f
C1033 VSS.t21 VSS 0.09193f
C1034 VSS.t323 VSS 0.0937f
C1035 VSS.t105 VSS 0.09193f
C1036 VSS.t19 VSS 0.09193f
C1037 VSS.t169 VSS 0.09193f
C1038 VSS.t103 VSS 0.09193f
C1039 VSS.t337 VSS 0.09193f
C1040 VSS.t167 VSS 0.09193f
C1041 VSS.t253 VSS 0.09193f
C1042 VSS.t335 VSS 0.09193f
C1043 VSS.t25 VSS 0.09193f
C1044 VSS.t251 VSS 0.09193f
C1045 VSS.t109 VSS 0.09193f
C1046 VSS.t23 VSS 0.09193f
C1047 VSS.t89 VSS 0.09193f
C1048 VSS.t107 VSS 0.09193f
C1049 VSS.t59 VSS 0.09193f
C1050 VSS.t87 VSS 0.09193f
C1051 VSS.t177 VSS 0.09193f
C1052 VSS.t57 VSS 0.09193f
C1053 VSS.t29 VSS 0.09193f
C1054 VSS.t175 VSS 0.09193f
C1055 VSS.t111 VSS 0.0937f
C1056 VSS.t27 VSS 0.09193f
C1057 VSS.t367 VSS 0.10011f
C1058 VSS.t245 VSS 0.10203f
C1059 VSS.t231 VSS 0.10011f
C1060 VSS.t365 VSS 0.10011f
C1061 VSS.t235 VSS 0.10011f
C1062 VSS.t229 VSS 0.10011f
C1063 VSS.t143 VSS 0.10203f
C1064 VSS.t233 VSS 0.10011f
C1065 VSS.t33 VSS 0.09575f
C1066 VSS.t329 VSS 0.09759f
C1067 VSS.t35 VSS 0.09575f
C1068 VSS.t31 VSS 0.09575f
C1069 VSS.t137 VSS 0.09575f
C1070 VSS.t171 VSS 0.09575f
C1071 VSS.t255 VSS 0.09759f
C1072 VSS.t247 VSS 0.09575f
C1073 VSS.t301 VSS 0.0703f
C1074 VSS.t295 VSS 0.07165f
C1075 VSS.t303 VSS 0.0703f
C1076 VSS.t299 VSS 0.0703f
C1077 VSS.t309 VSS 0.0703f
C1078 VSS.t307 VSS 0.0703f
C1079 VSS.t311 VSS 0.07165f
C1080 VSS.t305 VSS 0.0703f
C1081 VSS.t283 VSS 0.0592f
C1082 VSS.t281 VSS 0.06033f
C1083 VSS.t285 VSS 0.06033f
C1084 VSS.t287 VSS 0.0592f
C1085 VSS.t289 VSS 0.0703f
C1086 VSS.t291 VSS 0.07165f
C1087 VSS.t297 VSS 0.07165f
C1088 VSS.t293 VSS 0.0703f
C1089 VDD.t322 VSS 2.89223f
C1090 VDD.t324 VSS 0.1404f
C1091 VDD.t108 VSS 0.1404f
C1092 VDD.t110 VSS 0.1404f
C1093 VDD.t104 VSS 0.1404f
C1094 VDD.t106 VSS 0.1404f
C1095 VDD.t210 VSS 0.1404f
C1096 VDD.t212 VSS 0.1404f
C1097 VDD.t350 VSS 0.1404f
C1098 VDD.t352 VSS 0.1404f
C1099 VDD.t76 VSS 0.1404f
C1100 VDD.t78 VSS 0.1404f
C1101 VDD.t180 VSS 0.1404f
C1102 VDD.t182 VSS 0.1404f
C1103 VDD.t24 VSS 0.1404f
C1104 VDD.t26 VSS 0.1404f
C1105 VDD.t156 VSS 0.1404f
C1106 VDD.t158 VSS 0.1404f
C1107 VDD.t338 VSS 0.1404f
C1108 VDD.t340 VSS 0.1404f
C1109 VDD.t100 VSS 0.1404f
C1110 VDD.t102 VSS 0.1404f
C1111 VDD.t206 VSS 0.1404f
C1112 VDD.t208 VSS 0.1404f
C1113 VDD.t346 VSS 0.1404f
C1114 VDD.t348 VSS 0.1404f
C1115 VDD.t176 VSS 0.1404f
C1116 VDD.t178 VSS 0.1404f
C1117 VDD.t152 VSS 0.1404f
C1118 VDD.t154 VSS 0.1404f
C1119 VDD.t342 VSS 0.1404f
C1120 VDD.t344 VSS 0.1404f
C1121 VDD.t72 VSS 0.1404f
C1122 VDD.t74 VSS 0.1404f
C1123 VDD.t20 VSS 0.1404f
C1124 VDD.t22 VSS 0.78624f
C1125 VDD.t34 VSS 0.78624f
C1126 VDD.t36 VSS 0.1404f
C1127 VDD.t54 VSS 0.1404f
C1128 VDD.t56 VSS 0.1404f
C1129 VDD.t38 VSS 0.1404f
C1130 VDD.t40 VSS 0.1404f
C1131 VDD.t242 VSS 0.1404f
C1132 VDD.t244 VSS 0.1404f
C1133 VDD.t246 VSS 0.1404f
C1134 VDD.t248 VSS 0.1404f
C1135 VDD.t238 VSS 0.1404f
C1136 VDD.t240 VSS 0.1404f
C1137 VDD.t8 VSS 0.1404f
C1138 VDD.t10 VSS 0.1404f
C1139 VDD.t84 VSS 0.1404f
C1140 VDD.t86 VSS 0.1404f
C1141 VDD.t218 VSS 0.1404f
C1142 VDD.t220 VSS 0.1404f
C1143 VDD.t88 VSS 0.1404f
C1144 VDD.t90 VSS 0.1404f
C1145 VDD.t138 VSS 0.1404f
C1146 VDD.t140 VSS 0.1404f
C1147 VDD.t134 VSS 0.1404f
C1148 VDD.t136 VSS 0.78624f
C1149 VDD.t316 VSS 0.78624f
C1150 VDD.t204 VSS 0.1404f
C1151 VDD.t124 VSS 0.1404f
C1152 VDD.t46 VSS 0.1404f
C1153 VDD.t18 VSS 0.1404f
C1154 VDD.t366 VSS 0.1404f
C1155 VDD.t14 VSS 0.1404f
C1156 VDD.t16 VSS 0.78624f
C1157 VDD.t160 VSS 0.78624f
C1158 VDD.t188 VSS 0.1404f
C1159 VDD.t162 VSS 0.1404f
C1160 VDD.t48 VSS 0.1404f
C1161 VDD.t360 VSS 0.1404f
C1162 VDD.t190 VSS 0.1404f
C1163 VDD.t226 VSS 0.1404f
C1164 VDD.t250 VSS 0.78624f
C1165 VDD.t274 VSS 0.78624f
C1166 VDD.t272 VSS 0.1404f
C1167 VDD.t270 VSS 0.1404f
C1168 VDD.t268 VSS 0.1404f
C1169 VDD.t266 VSS 0.1404f
C1170 VDD.t262 VSS 0.1404f
C1171 VDD.t264 VSS 0.1404f
C1172 VDD.t252 VSS 0.78624f
C1173 VDD.t312 VSS 0.78624f
C1174 VDD.t314 VSS 0.1404f
C1175 VDD.t310 VSS 0.1404f
C1176 VDD.t308 VSS 0.78624f
C1177 VDD.t260 VSS 0.78624f
C1178 VDD.t258 VSS 0.1404f
C1179 VDD.t256 VSS 0.1404f
C1180 VDD.t254 VSS 0.78693f
C1181 VDD.t21 VSS 0.11036f
C1182 VDD.t23 VSS 0.11229f
C1183 VDD.n1 VSS 0.05261f
C1184 VDD.t73 VSS 0.11036f
C1185 VDD.t75 VSS 0.11036f
C1186 VDD.n2 VSS 0.0522f
C1187 VDD.n3 VSS 0.02645f
C1188 VDD.t343 VSS 0.11036f
C1189 VDD.t345 VSS 0.11036f
C1190 VDD.n4 VSS 0.0522f
C1191 VDD.n5 VSS 0.01498f
C1192 VDD.t153 VSS 0.11036f
C1193 VDD.t155 VSS 0.11036f
C1194 VDD.n6 VSS 0.0522f
C1195 VDD.n7 VSS 0.01498f
C1196 VDD.t177 VSS 0.11036f
C1197 VDD.t179 VSS 0.11036f
C1198 VDD.n8 VSS 0.0522f
C1199 VDD.n9 VSS 0.01498f
C1200 VDD.t347 VSS 0.11036f
C1201 VDD.t349 VSS 0.11036f
C1202 VDD.n10 VSS 0.0522f
C1203 VDD.n11 VSS 0.01498f
C1204 VDD.t207 VSS 0.11036f
C1205 VDD.t209 VSS 0.11036f
C1206 VDD.n12 VSS 0.0522f
C1207 VDD.n13 VSS 0.01498f
C1208 VDD.t101 VSS 0.11036f
C1209 VDD.t103 VSS 0.11036f
C1210 VDD.n14 VSS 0.0522f
C1211 VDD.n15 VSS 0.01498f
C1212 VDD.t339 VSS 0.11036f
C1213 VDD.t341 VSS 0.11036f
C1214 VDD.n16 VSS 0.0522f
C1215 VDD.n17 VSS 0.01498f
C1216 VDD.t157 VSS 0.11036f
C1217 VDD.t159 VSS 0.11036f
C1218 VDD.n18 VSS 0.0522f
C1219 VDD.n19 VSS 0.01498f
C1220 VDD.t25 VSS 0.11036f
C1221 VDD.t27 VSS 0.11036f
C1222 VDD.n20 VSS 0.0522f
C1223 VDD.n21 VSS 0.01498f
C1224 VDD.t181 VSS 0.11036f
C1225 VDD.t183 VSS 0.11036f
C1226 VDD.n22 VSS 0.0522f
C1227 VDD.n23 VSS 0.01498f
C1228 VDD.t77 VSS 0.11036f
C1229 VDD.t79 VSS 0.11036f
C1230 VDD.n24 VSS 0.0522f
C1231 VDD.n25 VSS 0.01498f
C1232 VDD.t351 VSS 0.11036f
C1233 VDD.t353 VSS 0.11036f
C1234 VDD.n26 VSS 0.0522f
C1235 VDD.n27 VSS 0.01498f
C1236 VDD.t211 VSS 0.11036f
C1237 VDD.t213 VSS 0.11036f
C1238 VDD.n28 VSS 0.0522f
C1239 VDD.n29 VSS 0.01498f
C1240 VDD.t105 VSS 0.11036f
C1241 VDD.t107 VSS 0.11036f
C1242 VDD.n30 VSS 0.0522f
C1243 VDD.n31 VSS 0.01498f
C1244 VDD.t109 VSS 0.11036f
C1245 VDD.t111 VSS 0.11036f
C1246 VDD.n32 VSS 0.0522f
C1247 VDD.n33 VSS 0.01498f
C1248 VDD.t323 VSS 0.11229f
C1249 VDD.t325 VSS 0.11036f
C1250 VDD.n34 VSS 0.0522f
C1251 VDD.n35 VSS 0.1095f
C1252 VDD.t135 VSS 0.10202f
C1253 VDD.t137 VSS 0.10378f
C1254 VDD.n36 VSS 0.05261f
C1255 VDD.t139 VSS 0.10202f
C1256 VDD.t141 VSS 0.10202f
C1257 VDD.n37 VSS 0.0522f
C1258 VDD.n38 VSS 0.02645f
C1259 VDD.t89 VSS 0.10202f
C1260 VDD.t91 VSS 0.10202f
C1261 VDD.n39 VSS 0.0522f
C1262 VDD.n40 VSS 0.01498f
C1263 VDD.t219 VSS 0.10202f
C1264 VDD.t221 VSS 0.10202f
C1265 VDD.n41 VSS 0.0522f
C1266 VDD.n42 VSS 0.01498f
C1267 VDD.t85 VSS 0.10202f
C1268 VDD.t87 VSS 0.10202f
C1269 VDD.n43 VSS 0.0522f
C1270 VDD.n44 VSS 0.01498f
C1271 VDD.t9 VSS 0.10202f
C1272 VDD.t11 VSS 0.10202f
C1273 VDD.n45 VSS 0.0522f
C1274 VDD.n46 VSS 0.01498f
C1275 VDD.t239 VSS 0.10202f
C1276 VDD.t241 VSS 0.10202f
C1277 VDD.n47 VSS 0.0522f
C1278 VDD.n48 VSS 0.01498f
C1279 VDD.t247 VSS 0.10202f
C1280 VDD.t249 VSS 0.10202f
C1281 VDD.n49 VSS 0.0522f
C1282 VDD.n50 VSS 0.01498f
C1283 VDD.t243 VSS 0.10202f
C1284 VDD.t245 VSS 0.10202f
C1285 VDD.n51 VSS 0.0522f
C1286 VDD.n52 VSS 0.01498f
C1287 VDD.t39 VSS 0.10202f
C1288 VDD.t41 VSS 0.10202f
C1289 VDD.n53 VSS 0.0522f
C1290 VDD.n54 VSS 0.01498f
C1291 VDD.t55 VSS 0.10202f
C1292 VDD.t57 VSS 0.10202f
C1293 VDD.n55 VSS 0.0522f
C1294 VDD.n56 VSS 0.01498f
C1295 VDD.t35 VSS 0.10378f
C1296 VDD.t37 VSS 0.10202f
C1297 VDD.n57 VSS 0.0522f
C1298 VDD.n58 VSS 0.05847f
C1299 VDD.n59 VSS 1.9521f
C1300 VDD.t15 VSS 0.11019f
C1301 VDD.t17 VSS 0.11211f
C1302 VDD.n60 VSS 0.05261f
C1303 VDD.t19 VSS 0.11019f
C1304 VDD.t367 VSS 0.11019f
C1305 VDD.n61 VSS 0.0522f
C1306 VDD.n62 VSS 0.02645f
C1307 VDD.t125 VSS 0.11019f
C1308 VDD.t47 VSS 0.11019f
C1309 VDD.n63 VSS 0.0522f
C1310 VDD.n64 VSS 0.01498f
C1311 VDD.t317 VSS 0.11211f
C1312 VDD.t205 VSS 0.11019f
C1313 VDD.n65 VSS 0.0522f
C1314 VDD.n66 VSS 0.05847f
C1315 VDD.n67 VSS 0.81734f
C1316 VDD.t227 VSS 0.10584f
C1317 VDD.t251 VSS 0.10767f
C1318 VDD.n68 VSS 0.05261f
C1319 VDD.t361 VSS 0.10584f
C1320 VDD.t191 VSS 0.10584f
C1321 VDD.n69 VSS 0.0522f
C1322 VDD.n70 VSS 0.02645f
C1323 VDD.t163 VSS 0.10584f
C1324 VDD.t49 VSS 0.10584f
C1325 VDD.n71 VSS 0.0522f
C1326 VDD.n72 VSS 0.01498f
C1327 VDD.t161 VSS 0.10767f
C1328 VDD.t189 VSS 0.10584f
C1329 VDD.n73 VSS 0.0522f
C1330 VDD.n74 VSS 0.05847f
C1331 VDD.n75 VSS 0.56912f
C1332 VDD.t265 VSS 0.08143f
C1333 VDD.t253 VSS 0.08279f
C1334 VDD.n76 VSS 0.05261f
C1335 VDD.t267 VSS 0.08143f
C1336 VDD.t263 VSS 0.08143f
C1337 VDD.n77 VSS 0.0522f
C1338 VDD.n78 VSS 0.02645f
C1339 VDD.t271 VSS 0.08143f
C1340 VDD.t269 VSS 0.08143f
C1341 VDD.n79 VSS 0.0522f
C1342 VDD.n80 VSS 0.01498f
C1343 VDD.t275 VSS 0.08279f
C1344 VDD.t273 VSS 0.08143f
C1345 VDD.n81 VSS 0.0522f
C1346 VDD.n82 VSS 0.05847f
C1347 VDD.n83 VSS 0.56912f
C1348 VDD.t311 VSS 0.06928f
C1349 VDD.t309 VSS 0.07042f
C1350 VDD.n84 VSS 0.05261f
C1351 VDD.t313 VSS 0.07042f
C1352 VDD.t315 VSS 0.06928f
C1353 VDD.n85 VSS 0.0522f
C1354 VDD.n86 VSS 0.06994f
C1355 VDD.n87 VSS 0.50706f
C1356 VDD.t257 VSS 0.08143f
C1357 VDD.t255 VSS 0.08279f
C1358 VDD.n88 VSS 0.05261f
C1359 VDD.t261 VSS 0.08279f
C1360 VDD.t259 VSS 0.08143f
C1361 VDD.n89 VSS 0.0522f
C1362 VDD.n90 VSS 0.06994f
C1363 VDD.n91 VSS 0.57559f
C1364 VDD.n92 VSS 46.5725f
C1365 VDD.n93 VSS 77.8231f
C1366 VDD.t168 VSS 2.89223f
C1367 VDD.t144 VSS 0.1404f
C1368 VDD.t332 VSS 0.1404f
C1369 VDD.t132 VSS 0.1404f
C1370 VDD.t130 VSS 0.1404f
C1371 VDD.t82 VSS 0.1404f
C1372 VDD.t32 VSS 0.1404f
C1373 VDD.t6 VSS 0.1404f
C1374 VDD.t52 VSS 0.1404f
C1375 VDD.t216 VSS 0.1404f
C1376 VDD.t80 VSS 0.1404f
C1377 VDD.t30 VSS 0.1404f
C1378 VDD.t4 VSS 0.1404f
C1379 VDD.t50 VSS 0.1404f
C1380 VDD.t214 VSS 0.1404f
C1381 VDD.t236 VSS 0.1404f
C1382 VDD.t98 VSS 0.1404f
C1383 VDD.t330 VSS 0.1404f
C1384 VDD.t96 VSS 0.1404f
C1385 VDD.t66 VSS 0.1404f
C1386 VDD.t2 VSS 0.1404f
C1387 VDD.t318 VSS 0.1404f
C1388 VDD.t194 VSS 0.1404f
C1389 VDD.t118 VSS 0.1404f
C1390 VDD.t94 VSS 0.1404f
C1391 VDD.t166 VSS 0.1404f
C1392 VDD.t142 VSS 0.1404f
C1393 VDD.t328 VSS 0.1404f
C1394 VDD.t192 VSS 0.1404f
C1395 VDD.t112 VSS 0.1404f
C1396 VDD.t92 VSS 0.1404f
C1397 VDD.t28 VSS 0.1404f
C1398 VDD.t58 VSS 0.1404f
C1399 VDD.t64 VSS 0.1404f
C1400 VDD.t164 VSS 0.1404f
C1401 VDD.t0 VSS 0.78624f
C1402 VDD.t320 VSS 0.78624f
C1403 VDD.t200 VSS 0.1404f
C1404 VDD.t202 VSS 0.1404f
C1405 VDD.t172 VSS 0.1404f
C1406 VDD.t174 VSS 0.1404f
C1407 VDD.t148 VSS 0.1404f
C1408 VDD.t150 VSS 0.1404f
C1409 VDD.t334 VSS 0.1404f
C1410 VDD.t336 VSS 0.1404f
C1411 VDD.t196 VSS 0.1404f
C1412 VDD.t198 VSS 0.1404f
C1413 VDD.t120 VSS 0.1404f
C1414 VDD.t122 VSS 0.1404f
C1415 VDD.t114 VSS 0.1404f
C1416 VDD.t116 VSS 0.1404f
C1417 VDD.t42 VSS 0.1404f
C1418 VDD.t44 VSS 0.1404f
C1419 VDD.t60 VSS 0.1404f
C1420 VDD.t62 VSS 0.1404f
C1421 VDD.t68 VSS 0.1404f
C1422 VDD.t70 VSS 0.1404f
C1423 VDD.t170 VSS 0.1404f
C1424 VDD.t12 VSS 0.1404f
C1425 VDD.t146 VSS 0.78624f
C1426 VDD.t228 VSS 0.78624f
C1427 VDD.t222 VSS 0.1404f
C1428 VDD.t224 VSS 0.1404f
C1429 VDD.t354 VSS 0.1404f
C1430 VDD.t356 VSS 0.1404f
C1431 VDD.t184 VSS 0.1404f
C1432 VDD.t186 VSS 0.1404f
C1433 VDD.t358 VSS 0.78624f
C1434 VDD.t326 VSS 0.78624f
C1435 VDD.t232 VSS 0.1404f
C1436 VDD.t234 VSS 0.1404f
C1437 VDD.t362 VSS 0.1404f
C1438 VDD.t364 VSS 0.1404f
C1439 VDD.t126 VSS 0.1404f
C1440 VDD.t128 VSS 0.1404f
C1441 VDD.t230 VSS 0.78624f
C1442 VDD.t306 VSS 0.78624f
C1443 VDD.t304 VSS 0.1404f
C1444 VDD.t302 VSS 0.1404f
C1445 VDD.t300 VSS 0.1404f
C1446 VDD.t298 VSS 0.1404f
C1447 VDD.t294 VSS 0.1404f
C1448 VDD.t296 VSS 0.1404f
C1449 VDD.t284 VSS 0.78624f
C1450 VDD.t282 VSS 0.78624f
C1451 VDD.t280 VSS 0.1404f
C1452 VDD.t278 VSS 0.1404f
C1453 VDD.t276 VSS 0.78624f
C1454 VDD.t292 VSS 0.78624f
C1455 VDD.t290 VSS 0.1404f
C1456 VDD.t286 VSS 0.1404f
C1457 VDD.t288 VSS 0.78693f
C1458 VDD.t165 VSS 0.11036f
C1459 VDD.t1 VSS 0.11229f
C1460 VDD.n94 VSS 0.05261f
C1461 VDD.t59 VSS 0.11036f
C1462 VDD.t65 VSS 0.11036f
C1463 VDD.n95 VSS 0.0522f
C1464 VDD.n96 VSS 0.02645f
C1465 VDD.t93 VSS 0.11036f
C1466 VDD.t29 VSS 0.11036f
C1467 VDD.n97 VSS 0.0522f
C1468 VDD.n98 VSS 0.01498f
C1469 VDD.t193 VSS 0.11036f
C1470 VDD.t113 VSS 0.11036f
C1471 VDD.n99 VSS 0.0522f
C1472 VDD.n100 VSS 0.01498f
C1473 VDD.t143 VSS 0.11036f
C1474 VDD.t329 VSS 0.11036f
C1475 VDD.n101 VSS 0.0522f
C1476 VDD.n102 VSS 0.01498f
C1477 VDD.t95 VSS 0.11036f
C1478 VDD.t167 VSS 0.11036f
C1479 VDD.n103 VSS 0.0522f
C1480 VDD.n104 VSS 0.01498f
C1481 VDD.t195 VSS 0.11036f
C1482 VDD.t119 VSS 0.11036f
C1483 VDD.n105 VSS 0.0522f
C1484 VDD.n106 VSS 0.01498f
C1485 VDD.t3 VSS 0.11036f
C1486 VDD.t319 VSS 0.11036f
C1487 VDD.n107 VSS 0.0522f
C1488 VDD.n108 VSS 0.01498f
C1489 VDD.t97 VSS 0.11036f
C1490 VDD.t67 VSS 0.11036f
C1491 VDD.n109 VSS 0.0522f
C1492 VDD.n110 VSS 0.01498f
C1493 VDD.t99 VSS 0.11036f
C1494 VDD.t331 VSS 0.11036f
C1495 VDD.n111 VSS 0.0522f
C1496 VDD.n112 VSS 0.01498f
C1497 VDD.t215 VSS 0.11036f
C1498 VDD.t237 VSS 0.11036f
C1499 VDD.n113 VSS 0.0522f
C1500 VDD.n114 VSS 0.01498f
C1501 VDD.t5 VSS 0.11036f
C1502 VDD.t51 VSS 0.11036f
C1503 VDD.n115 VSS 0.0522f
C1504 VDD.n116 VSS 0.01498f
C1505 VDD.t81 VSS 0.11036f
C1506 VDD.t31 VSS 0.11036f
C1507 VDD.n117 VSS 0.0522f
C1508 VDD.n118 VSS 0.01498f
C1509 VDD.t53 VSS 0.11036f
C1510 VDD.t217 VSS 0.11036f
C1511 VDD.n119 VSS 0.0522f
C1512 VDD.n120 VSS 0.01498f
C1513 VDD.t33 VSS 0.11036f
C1514 VDD.t7 VSS 0.11036f
C1515 VDD.n121 VSS 0.0522f
C1516 VDD.n122 VSS 0.01498f
C1517 VDD.t131 VSS 0.11036f
C1518 VDD.t83 VSS 0.11036f
C1519 VDD.n123 VSS 0.0522f
C1520 VDD.n124 VSS 0.01498f
C1521 VDD.t333 VSS 0.11036f
C1522 VDD.t133 VSS 0.11036f
C1523 VDD.n125 VSS 0.0522f
C1524 VDD.n126 VSS 0.01498f
C1525 VDD.t169 VSS 0.11229f
C1526 VDD.t145 VSS 0.11036f
C1527 VDD.n127 VSS 0.0522f
C1528 VDD.n128 VSS 0.1095f
C1529 VDD.t13 VSS 0.10202f
C1530 VDD.t147 VSS 0.10378f
C1531 VDD.n129 VSS 0.05261f
C1532 VDD.t71 VSS 0.10202f
C1533 VDD.t171 VSS 0.10202f
C1534 VDD.n130 VSS 0.0522f
C1535 VDD.n131 VSS 0.02645f
C1536 VDD.t63 VSS 0.10202f
C1537 VDD.t69 VSS 0.10202f
C1538 VDD.n132 VSS 0.0522f
C1539 VDD.n133 VSS 0.01498f
C1540 VDD.t45 VSS 0.10202f
C1541 VDD.t61 VSS 0.10202f
C1542 VDD.n134 VSS 0.0522f
C1543 VDD.n135 VSS 0.01498f
C1544 VDD.t117 VSS 0.10202f
C1545 VDD.t43 VSS 0.10202f
C1546 VDD.n136 VSS 0.0522f
C1547 VDD.n137 VSS 0.01498f
C1548 VDD.t123 VSS 0.10202f
C1549 VDD.t115 VSS 0.10202f
C1550 VDD.n138 VSS 0.0522f
C1551 VDD.n139 VSS 0.01498f
C1552 VDD.t199 VSS 0.10202f
C1553 VDD.t121 VSS 0.10202f
C1554 VDD.n140 VSS 0.0522f
C1555 VDD.n141 VSS 0.01498f
C1556 VDD.t337 VSS 0.10202f
C1557 VDD.t197 VSS 0.10202f
C1558 VDD.n142 VSS 0.0522f
C1559 VDD.n143 VSS 0.01498f
C1560 VDD.t151 VSS 0.10202f
C1561 VDD.t335 VSS 0.10202f
C1562 VDD.n144 VSS 0.0522f
C1563 VDD.n145 VSS 0.01498f
C1564 VDD.t175 VSS 0.10202f
C1565 VDD.t149 VSS 0.10202f
C1566 VDD.n146 VSS 0.0522f
C1567 VDD.n147 VSS 0.01498f
C1568 VDD.t203 VSS 0.10202f
C1569 VDD.t173 VSS 0.10202f
C1570 VDD.n148 VSS 0.0522f
C1571 VDD.n149 VSS 0.01498f
C1572 VDD.t321 VSS 0.10378f
C1573 VDD.t201 VSS 0.10202f
C1574 VDD.n150 VSS 0.0522f
C1575 VDD.n151 VSS 0.05847f
C1576 VDD.n152 VSS 1.9521f
C1577 VDD.t187 VSS 0.11019f
C1578 VDD.t359 VSS 0.11211f
C1579 VDD.n153 VSS 0.05261f
C1580 VDD.t357 VSS 0.11019f
C1581 VDD.t185 VSS 0.11019f
C1582 VDD.n154 VSS 0.0522f
C1583 VDD.n155 VSS 0.02645f
C1584 VDD.t225 VSS 0.11019f
C1585 VDD.t355 VSS 0.11019f
C1586 VDD.n156 VSS 0.0522f
C1587 VDD.n157 VSS 0.01498f
C1588 VDD.t229 VSS 0.11211f
C1589 VDD.t223 VSS 0.11019f
C1590 VDD.n158 VSS 0.0522f
C1591 VDD.n159 VSS 0.05847f
C1592 VDD.n160 VSS 0.81734f
C1593 VDD.t129 VSS 0.10584f
C1594 VDD.t231 VSS 0.10767f
C1595 VDD.n161 VSS 0.05261f
C1596 VDD.t365 VSS 0.10584f
C1597 VDD.t127 VSS 0.10584f
C1598 VDD.n162 VSS 0.0522f
C1599 VDD.n163 VSS 0.02645f
C1600 VDD.t235 VSS 0.10584f
C1601 VDD.t363 VSS 0.10584f
C1602 VDD.n164 VSS 0.0522f
C1603 VDD.n165 VSS 0.01498f
C1604 VDD.t327 VSS 0.10767f
C1605 VDD.t233 VSS 0.10584f
C1606 VDD.n166 VSS 0.0522f
C1607 VDD.n167 VSS 0.05847f
C1608 VDD.n168 VSS 0.56912f
C1609 VDD.t297 VSS 0.08039f
C1610 VDD.t285 VSS 0.08173f
C1611 VDD.n169 VSS 0.05261f
C1612 VDD.t299 VSS 0.08039f
C1613 VDD.t295 VSS 0.08039f
C1614 VDD.n170 VSS 0.0522f
C1615 VDD.n171 VSS 0.02645f
C1616 VDD.t303 VSS 0.08039f
C1617 VDD.t301 VSS 0.08039f
C1618 VDD.n172 VSS 0.0522f
C1619 VDD.n173 VSS 0.01498f
C1620 VDD.t307 VSS 0.08173f
C1621 VDD.t305 VSS 0.08039f
C1622 VDD.n174 VSS 0.0522f
C1623 VDD.n175 VSS 0.05847f
C1624 VDD.n176 VSS 0.56912f
C1625 VDD.t279 VSS 0.06928f
C1626 VDD.t277 VSS 0.07042f
C1627 VDD.n177 VSS 0.05261f
C1628 VDD.t283 VSS 0.07042f
C1629 VDD.t281 VSS 0.06928f
C1630 VDD.n178 VSS 0.0522f
C1631 VDD.n179 VSS 0.06994f
C1632 VDD.n180 VSS 0.50706f
C1633 VDD.t287 VSS 0.08039f
C1634 VDD.t289 VSS 0.08173f
C1635 VDD.n181 VSS 0.05261f
C1636 VDD.t293 VSS 0.08173f
C1637 VDD.t291 VSS 0.08039f
C1638 VDD.n182 VSS 0.0522f
C1639 VDD.n183 VSS 0.06994f
C1640 VDD.n184 VSS 0.57559f
C1641 VDD.n185 VSS 46.0548f
C1642 VDD.n186 VSS 78.3407f
C1643 VDD.n188 VSS 0.01401f
C1644 CLKN_HB.n0 VSS 0.03957f
C1645 CLKN_HB.n1 VSS 0.13671f
C1646 CLKN_HB.n2 VSS 0.06757f
C1647 CLKN_HB.n3 VSS 0.07243f
C1648 CLKN_HB.n4 VSS 0.07243f
C1649 CLKN_HB.n5 VSS 0.07243f
C1650 CLKN_HB.n6 VSS 0.06757f
C1651 CLKN_HB.n7 VSS 0.13671f
C1652 CLKN_HB.n8 VSS 0.07243f
C1653 CLKN_HB.n9 VSS 0.07243f
C1654 CLKN_HB.n10 VSS 0.07243f
C1655 CLKN_HB.n11 VSS 0.03957f
C1656 CLKN_HB.n12 VSS 0.23518f
C1657 CLKN_HB.n13 VSS 0.03957f
C1658 CLKN_HB.n14 VSS 0.13671f
C1659 CLKN_HB.n15 VSS 0.06757f
C1660 CLKN_HB.n16 VSS 0.07243f
C1661 CLKN_HB.n17 VSS 0.07243f
C1662 CLKN_HB.n18 VSS 0.07243f
C1663 CLKN_HB.n19 VSS 0.06757f
C1664 CLKN_HB.n20 VSS 0.13671f
C1665 CLKN_HB.n21 VSS 0.07243f
C1666 CLKN_HB.n22 VSS 0.07243f
C1667 CLKN_HB.n23 VSS 0.07243f
C1668 CLKN_HB.n24 VSS 0.03957f
C1669 CLKN_HB.n25 VSS 0.16162f
C1670 CLKN_HB.n26 VSS 0.99937f
C1671 CLKN_HB.n27 VSS 0.06661f
C1672 CLKN_HB.n28 VSS 0.07243f
C1673 CLKN_HB.n29 VSS 0.07243f
C1674 CLKN_HB.n30 VSS 0.06661f
C1675 CLKN_HB.n31 VSS 0.31796f
C1676 CLKN_HB.n32 VSS 0.06661f
C1677 CLKN_HB.n33 VSS 0.07243f
C1678 CLKN_HB.n34 VSS 0.07243f
C1679 CLKN_HB.n35 VSS 0.06661f
C1680 CLKN_HB.n36 VSS 0.25697f
C1681 CLKN_HB.n37 VSS 0.65633f
C1682 CLKN_HB.n38 VSS 1.29592f
C1683 CLKN_H.n0 VSS 0.05609f
C1684 CLKN_H.n1 VSS 0.06099f
C1685 CLKN_H.n2 VSS 0.06099f
C1686 CLKN_H.n3 VSS 0.05609f
C1687 CLKN_H.n4 VSS 0.26774f
C1688 CLKN_H.n5 VSS 0.05609f
C1689 CLKN_H.n6 VSS 0.06099f
C1690 CLKN_H.n7 VSS 0.06099f
C1691 CLKN_H.n8 VSS 0.05609f
C1692 CLKN_H.n9 VSS 0.21639f
C1693 CLKN_H.n10 VSS 1.63645f
C1694 O_CAPTURE_CLKB.t13 VSS 1.05677f
C1695 O_CAPTURE_CLKB.t8 VSS 0.24611f
C1696 O_CAPTURE_CLKB.t9 VSS 0.24611f
C1697 O_CAPTURE_CLKB.n0 VSS 0.7783f
C1698 O_CAPTURE_CLKB.n1 VSS 0.42781f
C1699 O_CAPTURE_CLKB.t14 VSS 0.24611f
C1700 O_CAPTURE_CLKB.t15 VSS 0.24611f
C1701 O_CAPTURE_CLKB.n2 VSS 0.7783f
C1702 O_CAPTURE_CLKB.n3 VSS 0.22332f
C1703 O_CAPTURE_CLKB.t4 VSS 0.24611f
C1704 O_CAPTURE_CLKB.t5 VSS 0.24611f
C1705 O_CAPTURE_CLKB.n4 VSS 0.7783f
C1706 O_CAPTURE_CLKB.n5 VSS 0.22332f
C1707 O_CAPTURE_CLKB.t7 VSS 1.04979f
C1708 O_CAPTURE_CLKB.n6 VSS 0.46205f
C1709 O_CAPTURE_CLKB.t11 VSS 1.05492f
C1710 O_CAPTURE_CLKB.t10 VSS 0.24611f
C1711 O_CAPTURE_CLKB.t3 VSS 0.24611f
C1712 O_CAPTURE_CLKB.n7 VSS 0.77256f
C1713 O_CAPTURE_CLKB.n8 VSS 0.4354f
C1714 O_CAPTURE_CLKB.t6 VSS 0.24611f
C1715 O_CAPTURE_CLKB.t2 VSS 0.24611f
C1716 O_CAPTURE_CLKB.n9 VSS 0.77256f
C1717 O_CAPTURE_CLKB.n10 VSS 0.22906f
C1718 O_CAPTURE_CLKB.t0 VSS 0.24611f
C1719 O_CAPTURE_CLKB.t1 VSS 0.24611f
C1720 O_CAPTURE_CLKB.n11 VSS 0.77256f
C1721 O_CAPTURE_CLKB.n12 VSS 0.22906f
C1722 O_CAPTURE_CLKB.t12 VSS 1.04792f
C1723 O_CAPTURE_CLKB.n13 VSS 0.3133f
C1724 O_CAPTURE_CLKB.n14 VSS 1.00544f
C1725 O_CAPTURE_CLK.t10 VSS 1.02147f
C1726 O_CAPTURE_CLK.t7 VSS 0.24424f
C1727 O_CAPTURE_CLK.t8 VSS 0.24424f
C1728 O_CAPTURE_CLK.n0 VSS 0.74605f
C1729 O_CAPTURE_CLK.n1 VSS 0.41008f
C1730 O_CAPTURE_CLK.t13 VSS 0.24424f
C1731 O_CAPTURE_CLK.t14 VSS 0.24424f
C1732 O_CAPTURE_CLK.n2 VSS 0.74605f
C1733 O_CAPTURE_CLK.n3 VSS 0.21407f
C1734 O_CAPTURE_CLK.t1 VSS 0.24424f
C1735 O_CAPTURE_CLK.t2 VSS 0.24424f
C1736 O_CAPTURE_CLK.n4 VSS 0.74605f
C1737 O_CAPTURE_CLK.n5 VSS 0.21407f
C1738 O_CAPTURE_CLK.t15 VSS 1.01477f
C1739 O_CAPTURE_CLK.n6 VSS 0.44291f
C1740 O_CAPTURE_CLK.t0 VSS 1.01969f
C1741 O_CAPTURE_CLK.t5 VSS 0.24424f
C1742 O_CAPTURE_CLK.t6 VSS 0.24424f
C1743 O_CAPTURE_CLK.n7 VSS 0.74055f
C1744 O_CAPTURE_CLK.n8 VSS 0.41736f
C1745 O_CAPTURE_CLK.t3 VSS 0.24424f
C1746 O_CAPTURE_CLK.t4 VSS 0.24424f
C1747 O_CAPTURE_CLK.n9 VSS 0.74055f
C1748 O_CAPTURE_CLK.n10 VSS 0.21957f
C1749 O_CAPTURE_CLK.t11 VSS 0.24424f
C1750 O_CAPTURE_CLK.t12 VSS 0.24424f
C1751 O_CAPTURE_CLK.n11 VSS 0.74055f
C1752 O_CAPTURE_CLK.n12 VSS 0.21957f
C1753 O_CAPTURE_CLK.t9 VSS 1.01298f
C1754 O_CAPTURE_CLK.n13 VSS 0.30032f
C1755 O_CAPTURE_CLK.n14 VSS 1.53503f
C1756 O_SENSE.t50 VSS 1.11225f
C1757 O_SENSE.t46 VSS 0.25861f
C1758 O_SENSE.t66 VSS 0.25861f
C1759 O_SENSE.n0 VSS 0.81957f
C1760 O_SENSE.n1 VSS 0.45049f
C1761 O_SENSE.t44 VSS 0.25861f
C1762 O_SENSE.t42 VSS 0.25861f
C1763 O_SENSE.n2 VSS 0.81957f
C1764 O_SENSE.n3 VSS 0.23517f
C1765 O_SENSE.t24 VSS 0.25861f
C1766 O_SENSE.t9 VSS 0.25861f
C1767 O_SENSE.n4 VSS 0.81957f
C1768 O_SENSE.n5 VSS 0.23517f
C1769 O_SENSE.t3 VSS 0.25861f
C1770 O_SENSE.t16 VSS 0.25861f
C1771 O_SENSE.n6 VSS 0.81957f
C1772 O_SENSE.n7 VSS 0.23517f
C1773 O_SENSE.t57 VSS 0.25861f
C1774 O_SENSE.t23 VSS 0.25861f
C1775 O_SENSE.n8 VSS 0.81957f
C1776 O_SENSE.n9 VSS 0.23517f
C1777 O_SENSE.t8 VSS 0.25861f
C1778 O_SENSE.t2 VSS 0.25861f
C1779 O_SENSE.n10 VSS 0.81957f
C1780 O_SENSE.n11 VSS 0.23517f
C1781 O_SENSE.t15 VSS 0.25861f
C1782 O_SENSE.t56 VSS 0.25861f
C1783 O_SENSE.n12 VSS 0.81957f
C1784 O_SENSE.n13 VSS 0.23517f
C1785 O_SENSE.t60 VSS 0.25861f
C1786 O_SENSE.t33 VSS 0.25861f
C1787 O_SENSE.n14 VSS 0.81957f
C1788 O_SENSE.n15 VSS 0.23517f
C1789 O_SENSE.t65 VSS 0.25861f
C1790 O_SENSE.t32 VSS 0.25861f
C1791 O_SENSE.n16 VSS 0.81957f
C1792 O_SENSE.n17 VSS 0.23517f
C1793 O_SENSE.t22 VSS 0.25861f
C1794 O_SENSE.t1 VSS 0.25861f
C1795 O_SENSE.n18 VSS 0.81957f
C1796 O_SENSE.n19 VSS 0.23517f
C1797 O_SENSE.t62 VSS 0.25861f
C1798 O_SENSE.t53 VSS 0.25861f
C1799 O_SENSE.n20 VSS 0.81957f
C1800 O_SENSE.n21 VSS 0.23517f
C1801 O_SENSE.t40 VSS 0.25861f
C1802 O_SENSE.t31 VSS 0.25861f
C1803 O_SENSE.n22 VSS 0.81957f
C1804 O_SENSE.n23 VSS 0.23517f
C1805 O_SENSE.t49 VSS 0.25861f
C1806 O_SENSE.t45 VSS 0.25861f
C1807 O_SENSE.n24 VSS 0.81957f
C1808 O_SENSE.n25 VSS 0.23517f
C1809 O_SENSE.t64 VSS 0.25861f
C1810 O_SENSE.t52 VSS 0.25861f
C1811 O_SENSE.n26 VSS 0.81957f
C1812 O_SENSE.n27 VSS 0.23517f
C1813 O_SENSE.t38 VSS 0.25861f
C1814 O_SENSE.t30 VSS 0.25861f
C1815 O_SENSE.n28 VSS 0.81957f
C1816 O_SENSE.n29 VSS 0.23517f
C1817 O_SENSE.t7 VSS 0.25861f
C1818 O_SENSE.t20 VSS 0.25861f
C1819 O_SENSE.n30 VSS 0.81957f
C1820 O_SENSE.n31 VSS 0.23517f
C1821 O_SENSE.t21 VSS 0.25861f
C1822 O_SENSE.t48 VSS 0.25861f
C1823 O_SENSE.n32 VSS 0.81957f
C1824 O_SENSE.n33 VSS 0.23517f
C1825 O_SENSE.t0 VSS 1.10489f
C1826 O_SENSE.n34 VSS 0.48655f
C1827 O_SENSE.t43 VSS 1.11029f
C1828 O_SENSE.t29 VSS 0.25861f
C1829 O_SENSE.t14 VSS 0.25861f
C1830 O_SENSE.n35 VSS 0.81353f
C1831 O_SENSE.n36 VSS 0.45849f
C1832 O_SENSE.t6 VSS 0.25861f
C1833 O_SENSE.t19 VSS 0.25861f
C1834 O_SENSE.n37 VSS 0.81353f
C1835 O_SENSE.n38 VSS 0.24121f
C1836 O_SENSE.t59 VSS 0.25861f
C1837 O_SENSE.t28 VSS 0.25861f
C1838 O_SENSE.n39 VSS 0.81353f
C1839 O_SENSE.n40 VSS 0.24121f
C1840 O_SENSE.t13 VSS 0.25861f
C1841 O_SENSE.t5 VSS 0.25861f
C1842 O_SENSE.n41 VSS 0.81353f
C1843 O_SENSE.n42 VSS 0.24121f
C1844 O_SENSE.t18 VSS 0.25861f
C1845 O_SENSE.t27 VSS 0.25861f
C1846 O_SENSE.n43 VSS 0.81353f
C1847 O_SENSE.n44 VSS 0.24121f
C1848 O_SENSE.t12 VSS 0.25861f
C1849 O_SENSE.t58 VSS 0.25861f
C1850 O_SENSE.n45 VSS 0.81353f
C1851 O_SENSE.n46 VSS 0.24121f
C1852 O_SENSE.t61 VSS 0.25861f
C1853 O_SENSE.t37 VSS 0.25861f
C1854 O_SENSE.n47 VSS 0.81353f
C1855 O_SENSE.n48 VSS 0.24121f
C1856 O_SENSE.t68 VSS 0.25861f
C1857 O_SENSE.t71 VSS 0.25861f
C1858 O_SENSE.n49 VSS 0.81353f
C1859 O_SENSE.n50 VSS 0.24121f
C1860 O_SENSE.t36 VSS 0.25861f
C1861 O_SENSE.t26 VSS 0.25861f
C1862 O_SENSE.n51 VSS 0.81353f
C1863 O_SENSE.n52 VSS 0.24121f
C1864 O_SENSE.t11 VSS 0.25861f
C1865 O_SENSE.t63 VSS 0.25861f
C1866 O_SENSE.n53 VSS 0.81353f
C1867 O_SENSE.n54 VSS 0.24121f
C1868 O_SENSE.t55 VSS 0.25861f
C1869 O_SENSE.t70 VSS 0.25861f
C1870 O_SENSE.n55 VSS 0.81353f
C1871 O_SENSE.n56 VSS 0.24121f
C1872 O_SENSE.t41 VSS 0.25861f
C1873 O_SENSE.t35 VSS 0.25861f
C1874 O_SENSE.n57 VSS 0.81353f
C1875 O_SENSE.n58 VSS 0.24121f
C1876 O_SENSE.t25 VSS 0.25861f
C1877 O_SENSE.t10 VSS 0.25861f
C1878 O_SENSE.n59 VSS 0.81353f
C1879 O_SENSE.n60 VSS 0.24121f
C1880 O_SENSE.t51 VSS 0.25861f
C1881 O_SENSE.t4 VSS 0.25861f
C1882 O_SENSE.n61 VSS 0.81353f
C1883 O_SENSE.n62 VSS 0.24121f
C1884 O_SENSE.t17 VSS 0.25861f
C1885 O_SENSE.t47 VSS 0.25861f
C1886 O_SENSE.n63 VSS 0.81353f
C1887 O_SENSE.n64 VSS 0.24121f
C1888 O_SENSE.t67 VSS 0.25861f
C1889 O_SENSE.t54 VSS 0.25861f
C1890 O_SENSE.n65 VSS 0.81353f
C1891 O_SENSE.n66 VSS 0.24121f
C1892 O_SENSE.t69 VSS 0.25861f
C1893 O_SENSE.t39 VSS 0.25861f
C1894 O_SENSE.n67 VSS 0.81353f
C1895 O_SENSE.n68 VSS 0.24121f
C1896 O_SENSE.t34 VSS 1.10293f
C1897 O_SENSE.n69 VSS 0.32992f
C1898 O_SENSE.n70 VSS 2.23053f
C1899 CLKP_HB.n0 VSS 0.04016f
C1900 CLKP_HB.n1 VSS 0.13873f
C1901 CLKP_HB.n2 VSS 0.06857f
C1902 CLKP_HB.n3 VSS 0.0735f
C1903 CLKP_HB.n4 VSS 0.0735f
C1904 CLKP_HB.n5 VSS 0.0735f
C1905 CLKP_HB.n6 VSS 0.06857f
C1906 CLKP_HB.n7 VSS 0.13873f
C1907 CLKP_HB.n8 VSS 0.0735f
C1908 CLKP_HB.n9 VSS 0.0735f
C1909 CLKP_HB.n10 VSS 0.0735f
C1910 CLKP_HB.n11 VSS 0.04016f
C1911 CLKP_HB.n12 VSS 0.23866f
C1912 CLKP_HB.n13 VSS 0.04016f
C1913 CLKP_HB.n14 VSS 0.13873f
C1914 CLKP_HB.n15 VSS 0.06857f
C1915 CLKP_HB.n16 VSS 0.0735f
C1916 CLKP_HB.n17 VSS 0.0735f
C1917 CLKP_HB.n18 VSS 0.0735f
C1918 CLKP_HB.n19 VSS 0.06857f
C1919 CLKP_HB.n20 VSS 0.13873f
C1920 CLKP_HB.n21 VSS 0.0735f
C1921 CLKP_HB.n22 VSS 0.0735f
C1922 CLKP_HB.n23 VSS 0.0735f
C1923 CLKP_HB.n24 VSS 0.04016f
C1924 CLKP_HB.n25 VSS 0.16401f
C1925 CLKP_HB.n26 VSS 1.01418f
C1926 CLKP_HB.n27 VSS 0.0676f
C1927 CLKP_HB.n28 VSS 0.0735f
C1928 CLKP_HB.n29 VSS 0.0735f
C1929 CLKP_HB.n30 VSS 0.0676f
C1930 CLKP_HB.n31 VSS 0.32267f
C1931 CLKP_HB.n32 VSS 0.0676f
C1932 CLKP_HB.n33 VSS 0.0735f
C1933 CLKP_HB.n34 VSS 0.0735f
C1934 CLKP_HB.n35 VSS 0.0676f
C1935 CLKP_HB.n36 VSS 0.26078f
C1936 CLKP_HB.n37 VSS 0.66606f
C1937 CLKP_HB.n38 VSS 1.22236f
C1938 CLKP_H.n0 VSS 0.05609f
C1939 CLKP_H.n1 VSS 0.06099f
C1940 CLKP_H.n2 VSS 0.06099f
C1941 CLKP_H.n3 VSS 0.05609f
C1942 CLKP_H.n4 VSS 0.26774f
C1943 CLKP_H.n5 VSS 0.05609f
C1944 CLKP_H.n6 VSS 0.06099f
C1945 CLKP_H.n7 VSS 0.06099f
C1946 CLKP_H.n8 VSS 0.05609f
C1947 CLKP_H.n9 VSS 0.21639f
C1948 CLKP_H.n10 VSS 1.63645f
C1949 E_CAPTURE_CLKB.t8 VSS 1.05677f
C1950 E_CAPTURE_CLKB.t10 VSS 0.24611f
C1951 E_CAPTURE_CLKB.t9 VSS 0.24611f
C1952 E_CAPTURE_CLKB.n0 VSS 0.7783f
C1953 E_CAPTURE_CLKB.n1 VSS 0.42781f
C1954 E_CAPTURE_CLKB.t1 VSS 0.24611f
C1955 E_CAPTURE_CLKB.t15 VSS 0.24611f
C1956 E_CAPTURE_CLKB.n2 VSS 0.7783f
C1957 E_CAPTURE_CLKB.n3 VSS 0.22332f
C1958 E_CAPTURE_CLKB.t11 VSS 0.24611f
C1959 E_CAPTURE_CLKB.t12 VSS 0.24611f
C1960 E_CAPTURE_CLKB.n4 VSS 0.7783f
C1961 E_CAPTURE_CLKB.n5 VSS 0.22332f
C1962 E_CAPTURE_CLKB.t13 VSS 1.04979f
C1963 E_CAPTURE_CLKB.n6 VSS 0.46205f
C1964 E_CAPTURE_CLKB.t0 VSS 1.05491f
C1965 E_CAPTURE_CLKB.t6 VSS 0.24611f
C1966 E_CAPTURE_CLKB.t4 VSS 0.24611f
C1967 E_CAPTURE_CLKB.n7 VSS 0.77256f
C1968 E_CAPTURE_CLKB.n8 VSS 0.4354f
C1969 E_CAPTURE_CLKB.t3 VSS 0.24611f
C1970 E_CAPTURE_CLKB.t7 VSS 0.24611f
C1971 E_CAPTURE_CLKB.n9 VSS 0.77256f
C1972 E_CAPTURE_CLKB.n10 VSS 0.22906f
C1973 E_CAPTURE_CLKB.t5 VSS 0.24611f
C1974 E_CAPTURE_CLKB.t2 VSS 0.24611f
C1975 E_CAPTURE_CLKB.n11 VSS 0.77256f
C1976 E_CAPTURE_CLKB.n12 VSS 0.22906f
C1977 E_CAPTURE_CLKB.t14 VSS 1.04792f
C1978 E_CAPTURE_CLKB.n13 VSS 0.3133f
C1979 E_CAPTURE_CLKB.n14 VSS 1.00544f
C1980 E_CAPTURE_CLK.t13 VSS 1.02147f
C1981 E_CAPTURE_CLK.t11 VSS 0.24424f
C1982 E_CAPTURE_CLK.t6 VSS 0.24424f
C1983 E_CAPTURE_CLK.n0 VSS 0.74605f
C1984 E_CAPTURE_CLK.n1 VSS 0.41008f
C1985 E_CAPTURE_CLK.t3 VSS 0.24424f
C1986 E_CAPTURE_CLK.t2 VSS 0.24424f
C1987 E_CAPTURE_CLK.n2 VSS 0.74605f
C1988 E_CAPTURE_CLK.n3 VSS 0.21407f
C1989 E_CAPTURE_CLK.t15 VSS 0.24424f
C1990 E_CAPTURE_CLK.t0 VSS 0.24424f
C1991 E_CAPTURE_CLK.n4 VSS 0.74605f
C1992 E_CAPTURE_CLK.n5 VSS 0.21407f
C1993 E_CAPTURE_CLK.t1 VSS 1.01477f
C1994 E_CAPTURE_CLK.n6 VSS 0.44291f
C1995 E_CAPTURE_CLK.t14 VSS 1.01969f
C1996 E_CAPTURE_CLK.t8 VSS 0.24424f
C1997 E_CAPTURE_CLK.t12 VSS 0.24424f
C1998 E_CAPTURE_CLK.n7 VSS 0.74055f
C1999 E_CAPTURE_CLK.n8 VSS 0.41736f
C2000 E_CAPTURE_CLK.t10 VSS 0.24424f
C2001 E_CAPTURE_CLK.t9 VSS 0.24424f
C2002 E_CAPTURE_CLK.n9 VSS 0.74055f
C2003 E_CAPTURE_CLK.n10 VSS 0.21957f
C2004 E_CAPTURE_CLK.t5 VSS 0.24424f
C2005 E_CAPTURE_CLK.t7 VSS 0.24424f
C2006 E_CAPTURE_CLK.n11 VSS 0.74055f
C2007 E_CAPTURE_CLK.n12 VSS 0.21957f
C2008 E_CAPTURE_CLK.t4 VSS 1.01298f
C2009 E_CAPTURE_CLK.n13 VSS 0.30032f
C2010 E_CAPTURE_CLK.n14 VSS 1.53503f
C2011 E_SENSE.t52 VSS 1.11225f
C2012 E_SENSE.t53 VSS 0.25861f
C2013 E_SENSE.t22 VSS 0.25861f
C2014 E_SENSE.n0 VSS 0.81957f
C2015 E_SENSE.n1 VSS 0.45049f
C2016 E_SENSE.t23 VSS 0.25861f
C2017 E_SENSE.t20 VSS 0.25861f
C2018 E_SENSE.n2 VSS 0.81957f
C2019 E_SENSE.n3 VSS 0.23517f
C2020 E_SENSE.t21 VSS 0.25861f
C2021 E_SENSE.t46 VSS 0.25861f
C2022 E_SENSE.n4 VSS 0.81957f
C2023 E_SENSE.n5 VSS 0.23517f
C2024 E_SENSE.t47 VSS 0.25861f
C2025 E_SENSE.t64 VSS 0.25861f
C2026 E_SENSE.n6 VSS 0.81957f
C2027 E_SENSE.n7 VSS 0.23517f
C2028 E_SENSE.t65 VSS 0.25861f
C2029 E_SENSE.t10 VSS 0.25861f
C2030 E_SENSE.n8 VSS 0.81957f
C2031 E_SENSE.n9 VSS 0.23517f
C2032 E_SENSE.t11 VSS 0.25861f
C2033 E_SENSE.t38 VSS 0.25861f
C2034 E_SENSE.n10 VSS 0.81957f
C2035 E_SENSE.n11 VSS 0.23517f
C2036 E_SENSE.t39 VSS 0.25861f
C2037 E_SENSE.t2 VSS 0.25861f
C2038 E_SENSE.n12 VSS 0.81957f
C2039 E_SENSE.n13 VSS 0.23517f
C2040 E_SENSE.t3 VSS 0.25861f
C2041 E_SENSE.t30 VSS 0.25861f
C2042 E_SENSE.n14 VSS 0.81957f
C2043 E_SENSE.n15 VSS 0.23517f
C2044 E_SENSE.t31 VSS 0.25861f
C2045 E_SENSE.t56 VSS 0.25861f
C2046 E_SENSE.n16 VSS 0.81957f
C2047 E_SENSE.n17 VSS 0.23517f
C2048 E_SENSE.t57 VSS 0.25861f
C2049 E_SENSE.t16 VSS 0.25861f
C2050 E_SENSE.n18 VSS 0.81957f
C2051 E_SENSE.n19 VSS 0.23517f
C2052 E_SENSE.t17 VSS 0.25861f
C2053 E_SENSE.t44 VSS 0.25861f
C2054 E_SENSE.n20 VSS 0.81957f
C2055 E_SENSE.n21 VSS 0.23517f
C2056 E_SENSE.t45 VSS 0.25861f
C2057 E_SENSE.t62 VSS 0.25861f
C2058 E_SENSE.n22 VSS 0.81957f
C2059 E_SENSE.n23 VSS 0.23517f
C2060 E_SENSE.t63 VSS 0.25861f
C2061 E_SENSE.t36 VSS 0.25861f
C2062 E_SENSE.n24 VSS 0.81957f
C2063 E_SENSE.n25 VSS 0.23517f
C2064 E_SENSE.t37 VSS 0.25861f
C2065 E_SENSE.t28 VSS 0.25861f
C2066 E_SENSE.n26 VSS 0.81957f
C2067 E_SENSE.n27 VSS 0.23517f
C2068 E_SENSE.t29 VSS 0.25861f
C2069 E_SENSE.t60 VSS 0.25861f
C2070 E_SENSE.n28 VSS 0.81957f
C2071 E_SENSE.n29 VSS 0.23517f
C2072 E_SENSE.t61 VSS 0.25861f
C2073 E_SENSE.t8 VSS 0.25861f
C2074 E_SENSE.n30 VSS 0.81957f
C2075 E_SENSE.n31 VSS 0.23517f
C2076 E_SENSE.t9 VSS 0.25861f
C2077 E_SENSE.t0 VSS 0.25861f
C2078 E_SENSE.n32 VSS 0.81957f
C2079 E_SENSE.n33 VSS 0.23517f
C2080 E_SENSE.t1 VSS 1.10489f
C2081 E_SENSE.n34 VSS 0.48655f
C2082 E_SENSE.t54 VSS 1.11029f
C2083 E_SENSE.t55 VSS 0.25861f
C2084 E_SENSE.t50 VSS 0.25861f
C2085 E_SENSE.n35 VSS 0.81353f
C2086 E_SENSE.n36 VSS 0.45849f
C2087 E_SENSE.t51 VSS 0.25861f
C2088 E_SENSE.t70 VSS 0.25861f
C2089 E_SENSE.n37 VSS 0.81353f
C2090 E_SENSE.n38 VSS 0.24121f
C2091 E_SENSE.t71 VSS 0.25861f
C2092 E_SENSE.t42 VSS 0.25861f
C2093 E_SENSE.n39 VSS 0.81353f
C2094 E_SENSE.n40 VSS 0.24121f
C2095 E_SENSE.t43 VSS 0.25861f
C2096 E_SENSE.t34 VSS 0.25861f
C2097 E_SENSE.n41 VSS 0.81353f
C2098 E_SENSE.n42 VSS 0.24121f
C2099 E_SENSE.t35 VSS 0.25861f
C2100 E_SENSE.t58 VSS 0.25861f
C2101 E_SENSE.n43 VSS 0.81353f
C2102 E_SENSE.n44 VSS 0.24121f
C2103 E_SENSE.t59 VSS 0.25861f
C2104 E_SENSE.t18 VSS 0.25861f
C2105 E_SENSE.n45 VSS 0.81353f
C2106 E_SENSE.n46 VSS 0.24121f
C2107 E_SENSE.t19 VSS 0.25861f
C2108 E_SENSE.t48 VSS 0.25861f
C2109 E_SENSE.n47 VSS 0.81353f
C2110 E_SENSE.n48 VSS 0.24121f
C2111 E_SENSE.t49 VSS 0.25861f
C2112 E_SENSE.t68 VSS 0.25861f
C2113 E_SENSE.n49 VSS 0.81353f
C2114 E_SENSE.n50 VSS 0.24121f
C2115 E_SENSE.t69 VSS 0.25861f
C2116 E_SENSE.t26 VSS 0.25861f
C2117 E_SENSE.n51 VSS 0.81353f
C2118 E_SENSE.n52 VSS 0.24121f
C2119 E_SENSE.t27 VSS 0.25861f
C2120 E_SENSE.t14 VSS 0.25861f
C2121 E_SENSE.n53 VSS 0.81353f
C2122 E_SENSE.n54 VSS 0.24121f
C2123 E_SENSE.t15 VSS 0.25861f
C2124 E_SENSE.t6 VSS 0.25861f
C2125 E_SENSE.n55 VSS 0.81353f
C2126 E_SENSE.n56 VSS 0.24121f
C2127 E_SENSE.t7 VSS 0.25861f
C2128 E_SENSE.t40 VSS 0.25861f
C2129 E_SENSE.n57 VSS 0.81353f
C2130 E_SENSE.n58 VSS 0.24121f
C2131 E_SENSE.t41 VSS 0.25861f
C2132 E_SENSE.t32 VSS 0.25861f
C2133 E_SENSE.n59 VSS 0.81353f
C2134 E_SENSE.n60 VSS 0.24121f
C2135 E_SENSE.t33 VSS 0.25861f
C2136 E_SENSE.t66 VSS 0.25861f
C2137 E_SENSE.n61 VSS 0.81353f
C2138 E_SENSE.n62 VSS 0.24121f
C2139 E_SENSE.t67 VSS 0.25861f
C2140 E_SENSE.t24 VSS 0.25861f
C2141 E_SENSE.n63 VSS 0.81353f
C2142 E_SENSE.n64 VSS 0.24121f
C2143 E_SENSE.t25 VSS 0.25861f
C2144 E_SENSE.t12 VSS 0.25861f
C2145 E_SENSE.n65 VSS 0.81353f
C2146 E_SENSE.n66 VSS 0.24121f
C2147 E_SENSE.t13 VSS 0.25861f
C2148 E_SENSE.t4 VSS 0.25861f
C2149 E_SENSE.n67 VSS 0.81353f
C2150 E_SENSE.n68 VSS 0.24121f
C2151 E_SENSE.t5 VSS 1.10293f
C2152 E_SENSE.n69 VSS 0.32992f
C2153 E_SENSE.n70 VSS 2.23053f
.ends
