* SPDX-License-Identifier: Apache-2.0
* source_revision: local_clock_fanout_v9_sampler_clkb_8_24_36_p36_capture4_8
.subckt cp_inv A Y VDD VSS params: MP=1 MN=1
XP Y A VDD VDD pfet_03v3 w=8u l=0.28u m={MP}
XN Y A VSS VSS nfet_03v3 w=8u l=0.28u m={MN}
.ends cp_inv

.subckt clock_fanout_buffer A Y VDD VSS params: PRE=4 OUT=8
XI0 A B VDD VSS cp_inv MP={PRE} MN={PRE}
XI1 B Y VDD VSS cp_inv MP={OUT} MN={OUT}
.ends clock_fanout_buffer

.subckt clock_fanout_sampler A Y VDD VSS
XI0 A B0 VDD VSS cp_inv MP=8 MN=8
XI1 B0 B1 VDD VSS cp_inv MP=24 MN=24
XI2 B1 Y VDD VSS cp_inv MP=36 MN=36
.ends clock_fanout_sampler

.subckt local_clock_fanout CLKP_H CLKP_HB CLKN_H CLKN_HB VDD VSS
+ E_SENSE E_CAPTURE_CLK E_CAPTURE_CLKB
+ O_SENSE O_CAPTURE_CLK O_CAPTURE_CLKB
XES CLKP_HB E_SENSE VDD VSS clock_fanout_sampler
XEC CLKP_H E_CAPTURE_CLK VDD VSS clock_fanout_buffer PRE=4 OUT=8
XECB CLKP_HB E_CAPTURE_CLKB VDD VSS clock_fanout_buffer PRE=4 OUT=8
XOS CLKN_HB O_SENSE VDD VSS clock_fanout_sampler
XOC CLKN_H O_CAPTURE_CLK VDD VSS clock_fanout_buffer PRE=4 OUT=8
XOCB CLKN_HB O_CAPTURE_CLKB VDD VSS clock_fanout_buffer PRE=4 OUT=8
.ends local_clock_fanout
