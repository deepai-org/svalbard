* SPDX-License-Identifier: Apache-2.0
* Two-stage low-load CML limiter for the dedicated 2.5 GT/s receive path.

.subckt cml_data_restorer_2p5_stage IN_P IN_N VBIAS VDD VSS OUT_P OUT_N
XRP VDD OUT_P VSS ppolyf_u r_width=2u r_length=3.6u
XRN VDD OUT_N VSS ppolyf_u r_width=2u r_length=3.6u
XIP OUT_P IN_P NTAIL VSS nfet_03v3 w=10u l=0.28u m=2
XIN OUT_N IN_N NTAIL VSS nfet_03v3 w=10u l=0.28u m=2
XTAIL NTAIL VBIAS VSS VSS nfet_03v3 w=12u l=0.28u m=4
.ends cml_data_restorer_2p5_stage

.subckt cml_data_restorer_2p5 IN_P IN_N VBIAS VDD VSS OUT_P OUT_N
XPRE IN_P IN_N VBIAS VDD VSS MID_P MID_N cml_data_restorer_2p5_stage
XDRV MID_P MID_N VBIAS VDD VSS OUT_P OUT_N cml_data_restorer_2p5_stage
.ends cml_data_restorer_2p5
