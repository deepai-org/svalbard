* PEX produced using /foss/tools/sak/sak-pex.sh with m=3 and s=1 (extresist threshold=0 mOhm, minres=1 mOhm, mindelay=0 ps)
* NGSPICE file created from cml_to_cmos_pex.ext - technology: gf180mcuD

.subckt cml_to_cmos_pex INP INN SENSE_CLK REGEN_CLK REGEN_CLKB CAPTURE_CLK CAPTURE_CLKB
+ VDD VSS OUTP OUTN SENSE_BOOST_CLK
X0 BP.t1 SXP.t18 VSS.t92 VSS.t91 nfet_03v3 ad=2.08p pd=8.52u as=2.08p ps=8.52u w=8u l=0.28u
X1 VDD.t49 SENSE_CLK.t7 SA.t5 VDD.t48 pfet_03v3 ad=2.08p pd=8.52u as=3.52p ps=16.88u w=8u l=0.28u
X2 VREGN.t5 REGEN_CLKB.t2 VDD.t153 VDD.t152 pfet_03v3 ad=2.08p pd=8.52u as=2.08p ps=8.52u w=8u l=0.28u
X3 VDD.t44 SXP.t21 BP.t8 VDD.t43 pfet_03v3 ad=2.08p pd=8.52u as=3.52p ps=16.88u w=8u l=0.28u
X4 NREGEN.t33 SA.t12 XN.t32 VSS.t109 nfet_03v3 ad=2.08p pd=8.52u as=2.08p ps=8.52u w=8u l=0.28u
X5 VDD.t106 XP.t45 SXP.t8 VDD.t105 pfet_03v3 ad=2.08p pd=8.52u as=2.08p ps=8.52u w=8u l=0.28u
X6 OUTN.t8 BN.t14 VSS.t80 VSS.t79 nfet_03v3 ad=2.08p pd=8.52u as=2.08p ps=8.52u w=8u l=0.28u
X7 OUTN.t0 BN.t12 VSS.t64 VSS.t63 nfet_03v3 ad=2.08p pd=8.52u as=2.08p ps=8.52u w=8u l=0.28u
X8 XN.t27 XP.t36 NREGEN.t25 VSS.t83 nfet_03v3 ad=2.08p pd=8.52u as=2.08p ps=8.52u w=8u l=0.28u
X9 VSS.t44 SENSE_CLK.t1 NTAIL.t4 VSS.t43 nfet_03v3 ad=2.08p pd=8.52u as=3.52p ps=16.88u w=8u l=0.28u
X10 SB.t6 SENSE_CLK.t2 VDD.t55 VDD.t54 pfet_03v3 ad=3.52p pd=16.88u as=2.08p ps=8.52u w=8u l=0.28u
X11 SXN.t8 XN.t48 VDD.t121 VDD.t120 pfet_03v3 ad=2.08p pd=8.52u as=2.08p ps=8.52u w=8u l=0.28u
X12 VSS.t116 SENSE_BOOST_CLK.t1 NTAIL.t10 VSS.t57 nfet_03v3 ad=2.08p pd=8.52u as=2.08p ps=8.52u w=8u l=0.28u
X13 SXN.t11 XN.t46 VDD.t169 VDD.t168 pfet_03v3 ad=2.08p pd=8.52u as=2.08p ps=8.52u w=8u l=0.28u
X14 NTAIL.t7 SENSE_BOOST_CLK.t4 VSS.t113 VSS.t47 nfet_03v3 ad=2.08p pd=8.52u as=2.08p ps=8.52u w=8u l=0.28u
X15 XP.t28 XN.t50 VREGP.t15 VDD.t167 pfet_03v3 ad=3.52p pd=16.88u as=2.08p ps=8.52u w=8u l=0.28u
X16 SB.t2 INN.t0 NTAIL.t1 VSS.t1 nfet_03v3 ad=3.52p pd=16.88u as=2.08p ps=8.52u w=8u l=0.28u
X17 VDD.t117 XN.t49 SXN.t6 VDD.t116 pfet_03v3 ad=2.08p pd=8.52u as=3.52p ps=16.88u w=8u l=0.28u
X18 VDD.t143 REGEN_CLKB.t9 VREGP.t6 VDD.t142 pfet_03v3 ad=2.08p pd=8.52u as=2.08p ps=8.52u w=8u l=0.28u
X19 VDD.t149 REGEN_CLKB.t5 VREGN.t2 VDD.t148 pfet_03v3 ad=2.08p pd=8.52u as=2.08p ps=8.52u w=8u l=0.28u
X20 VDD.t59 REGEN_CLK.t35 XP.t11 VDD.t58 pfet_03v3 ad=2.08p pd=8.52u as=3.52p ps=16.88u w=8u l=0.28u
X21 VDD.t127 XN.t47 SXN.t10 VDD.t126 pfet_03v3 ad=2.08p pd=8.52u as=2.08p ps=8.52u w=8u l=0.28u
X22 VSS.t111 XP.t39 SXP.t11 VSS.t110 nfet_03v3 ad=2.08p pd=8.52u as=2.08p ps=8.52u w=8u l=0.28u
X23 VREGP.t3 REGEN_CLKB.t12 VDD.t139 VDD.t138 pfet_03v3 ad=2.08p pd=8.52u as=2.08p ps=8.52u w=8u l=0.28u
X24 OUTP.t3 BP.t14 VSS.t9 VSS.t8 nfet_03v3 ad=2.08p pd=8.52u as=2.08p ps=8.52u w=8u l=0.28u
X25 XP.t10 REGEN_CLK.t20 XN.t12 VDD.t80 pfet_03v3 ad=3.52p pd=16.88u as=2.08p ps=8.52u w=8u l=0.28u
X26 XP.t22 SB.t11 NREGEN.t27 VSS.t99 nfet_03v3 ad=2.08p pd=8.52u as=2.08p ps=8.52u w=8u l=0.28u
X27 VREGP.t10 XN.t55 XP.t34 VDD.t4 pfet_03v3 ad=2.08p pd=8.52u as=2.08p ps=8.52u w=8u l=0.28u
X28 BN.t1 SXN.t16 VSS.t7 VSS.t6 nfet_03v3 ad=2.08p pd=8.52u as=2.08p ps=8.52u w=8u l=0.28u
X29 SXN.t3 XN.t40 VSS.t38 VSS.t37 nfet_03v3 ad=2.08p pd=8.52u as=2.08p ps=8.52u w=8u l=0.28u
X30 VREGP.t8 XN.t57 XP.t33 VDD.t37 pfet_03v3 ad=2.08p pd=8.52u as=3.52p ps=16.88u w=8u l=0.28u
X31 SXN.t9 XN.t42 VDD.t123 VDD.t122 pfet_03v3 ad=3.52p pd=16.88u as=2.08p ps=8.52u w=8u l=0.28u
X32 VSS.t36 BP.t13 OUTP.t12 VSS.t35 nfet_03v3 ad=2.08p pd=8.52u as=2.08p ps=8.52u w=8u l=0.28u
X33 XN.t14 REGEN_CLK.t25 XP.t5 VDD.t77 pfet_03v3 ad=2.08p pd=8.52u as=2.08p ps=8.52u w=8u l=0.28u
X34 VDD.t99 SXN.t21 BN.t4 VDD.t98 pfet_03v3 ad=2.08p pd=8.52u as=3.52p ps=16.88u w=8u l=0.28u
X35 XP.t29 XN.t54 VREGP.t11 VDD.t13 pfet_03v3 ad=2.08p pd=8.52u as=2.08p ps=8.52u w=8u l=0.28u
X36 VSS.t105 SXN.t17 BN.t7 VSS.t104 nfet_03v3 ad=2.08p pd=8.52u as=2.08p ps=8.52u w=8u l=0.28u
X37 XN.t1 SA.t11 NREGEN.t1 VSS.t3 nfet_03v3 ad=2.08p pd=8.52u as=2.08p ps=8.52u w=8u l=0.28u
X38 VSS.t13 XN.t41 SXN.t1 VSS.t12 nfet_03v3 ad=2.08p pd=8.52u as=3.52p ps=16.88u w=8u l=0.28u
X39 XP.t26 XN.t56 VREGP.t9 VDD.t22 pfet_03v3 ad=2.08p pd=8.52u as=2.08p ps=8.52u w=8u l=0.28u
X40 VDD.t166 BN.t19 OUTN.t11 VDD.t165 pfet_03v3 ad=2.08p pd=8.52u as=2.08p ps=8.52u w=8u l=0.28u
X41 VREGN.t12 XP.t53 XN.t33 VDD.t170 pfet_03v3 ad=2.08p pd=8.52u as=2.08p ps=8.52u w=8u l=0.28u
X42 OUTP.t0 BP.t16 VDD.t1 VDD.t0 pfet_03v3 ad=3.52p pd=16.88u as=2.08p ps=8.52u w=8u l=0.28u
X43 SA.t4 SENSE_CLK.t4 SB.t3 VDD.t51 pfet_03v3 ad=3.52p pd=16.88u as=2.08p ps=8.52u w=8u l=0.28u
X44 VREGP.t1 REGEN_CLKB.t14 VDD.t133 VDD.t132 pfet_03v3 ad=2.08p pd=8.52u as=2.08p ps=8.52u w=8u l=0.28u
X45 VREGN.t7 REGEN_CLKB.t0 VDD.t159 VDD.t158 pfet_03v3 ad=3.52p pd=16.88u as=2.08p ps=8.52u w=8u l=0.28u
X46 VDD.t82 REGEN_CLK.t19 XN.t16 VDD.t81 pfet_03v3 ad=2.08p pd=8.52u as=3.52p ps=16.88u w=8u l=0.28u
X47 VSS.t90 SXP.t15 BP.t4 VSS.t89 nfet_03v3 ad=2.08p pd=8.52u as=2.08p ps=8.52u w=8u l=0.28u
X48 VDD.t36 BP.t21 OUTP.t10 VDD.t35 pfet_03v3 ad=2.08p pd=8.52u as=2.08p ps=8.52u w=8u l=0.28u
X49 VSS.t42 SXP.t17 BP.t2 VSS.t41 nfet_03v3 ad=2.08p pd=8.52u as=2.08p ps=8.52u w=8u l=0.28u
X50 VDD.t161 BP.t23 OUTP.t13 VDD.t160 pfet_03v3 ad=2.08p pd=8.52u as=3.52p ps=16.88u w=8u l=0.28u
X51 VREGP.t7 REGEN_CLKB.t8 VDD.t147 VDD.t146 pfet_03v3 ad=3.52p pd=16.88u as=2.08p ps=8.52u w=8u l=0.28u
X52 SA.t6 SENSE_CLK.t6 VDD.t47 VDD.t46 pfet_03v3 ad=3.52p pd=16.88u as=2.08p ps=8.52u w=8u l=0.28u
X53 NREGEN.t3 SB.t12 XP.t0 VSS.t17 nfet_03v3 ad=2.08p pd=8.52u as=2.08p ps=8.52u w=8u l=0.28u
X54 VREGN.t1 REGEN_CLKB.t6 VDD.t131 VDD.t130 pfet_03v3 ad=2.08p pd=8.52u as=2.08p ps=8.52u w=8u l=0.28u
X55 BP.t9 SXP.t20 VDD.t42 VDD.t41 pfet_03v3 ad=3.52p pd=16.88u as=2.08p ps=8.52u w=8u l=0.28u
X56 SXP.t5 XP.t42 VDD.t28 VDD.t27 pfet_03v3 ad=3.52p pd=16.88u as=2.08p ps=8.52u w=8u l=0.28u
X57 NREGEN.t18 REGEN_CLK.t10 VDD.t95 VDD.t94 pfet_03v3 ad=3.52p pd=16.88u as=2.08p ps=8.52u w=8u l=0.28u
X58 SXP.t1 XP.t44 VDD.t10 VDD.t9 pfet_03v3 ad=2.08p pd=8.52u as=2.08p ps=8.52u w=8u l=0.28u
X59 VSS.t82 BN.t15 OUTN.t9 VSS.t81 nfet_03v3 ad=2.08p pd=8.52u as=3.52p ps=16.88u w=8u l=0.28u
X60 OUTP.t9 BP.t20 VDD.t34 VDD.t33 pfet_03v3 ad=2.08p pd=8.52u as=2.08p ps=8.52u w=8u l=0.28u
X61 VSS.t66 BN.t13 OUTN.t1 VSS.t65 nfet_03v3 ad=2.08p pd=8.52u as=2.08p ps=8.52u w=8u l=0.28u
X62 VDD.t137 REGEN_CLKB.t11 VREGP.t4 VDD.t136 pfet_03v3 ad=2.08p pd=8.52u as=2.08p ps=8.52u w=8u l=0.28u
X63 OUTP.t2 BP.t22 VDD.t12 VDD.t11 pfet_03v3 ad=2.08p pd=8.52u as=2.08p ps=8.52u w=8u l=0.28u
X64 VSS.t56 REGEN_CLK.t3 NREGEN.t13 VSS.t55 nfet_03v3 ad=2.08p pd=8.52u as=2.08p ps=8.52u w=8u l=0.28u
X65 VDD.t174 VSS.t125 SA.t0 VDD.t173 pfet_03v3 ad=3.52p pd=16.88u as=3.52p ps=16.88u w=8u l=0.28u
X66 VDD.t155 REGEN_CLKB.t3 VREGN.t4 VDD.t154 pfet_03v3 ad=2.08p pd=8.52u as=2.08p ps=8.52u w=8u l=0.28u
X67 VDD.t53 SENSE_CLK.t3 SB.t5 VDD.t52 pfet_03v3 ad=2.08p pd=8.52u as=3.52p ps=16.88u w=8u l=0.28u
X68 XN.t15 REGEN_CLK.t21 XP.t9 VDD.t79 pfet_03v3 ad=2.08p pd=8.52u as=2.08p ps=8.52u w=8u l=0.28u
X69 NREGEN.t10 REGEN_CLK.t6 VSS.t52 VSS.t51 nfet_03v3 ad=2.08p pd=8.52u as=2.08p ps=8.52u w=8u l=0.28u
X70 VDD.t57 REGEN_CLK.t9 NREGEN.t19 VDD.t56 pfet_03v3 ad=2.08p pd=8.52u as=3.52p ps=16.88u w=8u l=0.28u
X71 VDD.t32 XP.t43 SXP.t7 VDD.t31 pfet_03v3 ad=2.08p pd=8.52u as=2.08p ps=8.52u w=8u l=0.28u
X72 NREGEN.t30 SA.t10 XN.t30 VSS.t102 nfet_03v3 ad=2.08p pd=8.52u as=2.08p ps=8.52u w=8u l=0.28u
X73 VDD.t93 REGEN_CLK.t11 NREGEN.t17 VDD.t92 pfet_03v3 ad=2.08p pd=8.52u as=3.52p ps=16.88u w=8u l=0.28u
X74 XN.t4 SA.t7 NREGEN.t6 VSS.t24 nfet_03v3 ad=3.52p pd=16.88u as=2.08p ps=8.52u w=8u l=0.28u
X75 NREGEN.t21 SB.t8 XP.t19 VSS.t71 nfet_03v3 ad=2.08p pd=8.52u as=2.08p ps=8.52u w=8u l=0.28u
X76 VDD.t72 REGEN_CLK.t29 XP.t17 VDD.t71 pfet_03v3 ad=2.08p pd=8.52u as=2.08p ps=8.52u w=8u l=0.28u
X77 VDD.t86 REGEN_CLK.t17 XN.t18 VDD.t85 pfet_03v3 ad=2.08p pd=8.52u as=2.08p ps=8.52u w=8u l=0.28u
X78 VDD.t8 XP.t49 SXP.t0 VDD.t7 pfet_03v3 ad=2.08p pd=8.52u as=3.52p ps=16.88u w=8u l=0.28u
X79 NREGEN.t16 REGEN_CLK.t0 VSS.t62 VSS.t61 nfet_03v3 ad=3.52p pd=16.88u as=2.08p ps=8.52u w=8u l=0.28u
X80 NREGEN.t2 XN.t35 XP.t32 VSS.t14 nfet_03v3 ad=3.52p pd=16.88u as=2.08p ps=8.52u w=8u l=0.28u
X81 XP.t14 REGEN_CLK.t32 VDD.t62 VDD.t48 pfet_03v3 ad=2.08p pd=8.52u as=2.08p ps=8.52u w=8u l=0.28u
X82 NREGEN.t20 REGEN_CLK.t8 VDD.t97 VDD.t96 pfet_03v3 ad=3.52p pd=16.88u as=2.08p ps=8.52u w=8u l=0.28u
X83 SXP.t10 XP.t38 VSS.t78 VSS.t77 nfet_03v3 ad=3.52p pd=16.88u as=2.08p ps=8.52u w=8u l=0.28u
X84 XN.t21 REGEN_CLK.t14 VDD.t67 VDD.t66 pfet_03v3 ad=2.08p pd=8.52u as=2.08p ps=8.52u w=8u l=0.28u
X85 SXP.t6 XP.t48 VDD.t30 VDD.t29 pfet_03v3 ad=2.08p pd=8.52u as=2.08p ps=8.52u w=8u l=0.28u
X86 VSS.t21 BP.t11 OUTP.t8 VSS.t20 nfet_03v3 ad=2.08p pd=8.52u as=2.08p ps=8.52u w=8u l=0.28u
X87 XN.t24 REGEN_CLK.t27 XP.t3 VDD.t75 pfet_03v3 ad=2.08p pd=8.52u as=3.52p ps=16.88u w=8u l=0.28u
X88 NREGEN.t24 SA.t14 XN.t26 VSS.t76 nfet_03v3 ad=2.08p pd=8.52u as=3.52p ps=16.88u w=8u l=0.28u
X89 SB.t4 SENSE_CLK.t5 SA.t3 VDD.t50 pfet_03v3 ad=2.08p pd=8.52u as=3.52p ps=16.88u w=8u l=0.28u
X90 OUTP.t7 BP.t10 VSS.t19 VSS.t18 nfet_03v3 ad=3.52p pd=16.88u as=2.08p ps=8.52u w=8u l=0.28u
X91 VDD.t6 XN.t43 SXN.t0 VDD.t5 pfet_03v3 ad=2.08p pd=8.52u as=2.08p ps=8.52u w=8u l=0.28u
X92 NREGEN.t7 XP.t35 XN.t5 VSS.t27 nfet_03v3 ad=3.52p pd=16.88u as=2.08p ps=8.52u w=8u l=0.28u
X93 OUTP.t11 BP.t12 VSS.t34 VSS.t33 nfet_03v3 ad=2.08p pd=8.52u as=2.08p ps=8.52u w=8u l=0.28u
X94 VDD.t135 REGEN_CLKB.t13 VREGP.t2 VDD.t134 pfet_03v3 ad=2.08p pd=8.52u as=2.08p ps=8.52u w=8u l=0.28u
X95 VDD.t157 REGEN_CLKB.t1 VREGN.t6 VDD.t156 pfet_03v3 ad=2.08p pd=8.52u as=2.08p ps=8.52u w=8u l=0.28u
X96 XN.t10 REGEN_CLK.t23 XP.t7 VDD.t51 pfet_03v3 ad=2.08p pd=8.52u as=2.08p ps=8.52u w=8u l=0.28u
X97 VREGP.t12 XN.t53 XP.t24 VDD.t38 pfet_03v3 ad=2.08p pd=8.52u as=2.08p ps=8.52u w=8u l=0.28u
X98 BN.t8 SXN.t18 VSS.t107 VSS.t106 nfet_03v3 ad=2.08p pd=8.52u as=2.08p ps=8.52u w=8u l=0.28u
X99 OUTN.t4 BN.t20 VDD.t108 VDD.t107 pfet_03v3 ad=2.08p pd=8.52u as=2.08p ps=8.52u w=8u l=0.28u
X100 SXN.t2 XN.t44 VDD.t24 VDD.t23 pfet_03v3 ad=2.08p pd=8.52u as=2.08p ps=8.52u w=8u l=0.28u
X101 XN.t34 XP.t54 VREGN.t11 VDD.t175 pfet_03v3 ad=2.08p pd=8.52u as=2.08p ps=8.52u w=8u l=0.28u
X102 VSS.t85 SXN.t19 BN.t5 VSS.t84 nfet_03v3 ad=2.08p pd=8.52u as=3.52p ps=16.88u w=8u l=0.28u
X103 VSS.t50 REGEN_CLK.t7 NREGEN.t9 VSS.t49 nfet_03v3 ad=2.08p pd=8.52u as=3.52p ps=16.88u w=8u l=0.28u
X104 VDD.t110 BN.t21 OUTN.t5 VDD.t109 pfet_03v3 ad=2.08p pd=8.52u as=2.08p ps=8.52u w=8u l=0.28u
X105 XP.t20 SB.t9 NREGEN.t22 VSS.t72 nfet_03v3 ad=2.08p pd=8.52u as=2.08p ps=8.52u w=8u l=0.28u
X106 VREGP.t5 REGEN_CLKB.t10 VDD.t141 VDD.t140 pfet_03v3 ad=2.08p pd=8.52u as=2.08p ps=8.52u w=8u l=0.28u
X107 VREGN.t10 XP.t55 XN.t9 VDD.t45 pfet_03v3 ad=2.08p pd=8.52u as=2.08p ps=8.52u w=8u l=0.28u
X108 VREGN.t3 REGEN_CLKB.t4 VDD.t151 VDD.t150 pfet_03v3 ad=2.08p pd=8.52u as=2.08p ps=8.52u w=8u l=0.28u
X109 VDD.t172 VSS.t124 SB.t0 VDD.t171 pfet_03v3 ad=3.52p pd=16.88u as=3.52p ps=16.88u w=8u l=0.28u
X110 BP.t5 SXP.t14 VSS.t88 VSS.t87 nfet_03v3 ad=2.08p pd=8.52u as=2.08p ps=8.52u w=8u l=0.28u
X111 SXN.t5 XN.t38 VSS.t70 VSS.t69 nfet_03v3 ad=3.52p pd=16.88u as=2.08p ps=8.52u w=8u l=0.28u
X112 BN.t9 SXN.t12 VSS.t119 VSS.t118 nfet_03v3 ad=3.52p pd=16.88u as=2.08p ps=8.52u w=8u l=0.28u
X113 XN.t6 SA.t13 NREGEN.t8 VSS.t28 nfet_03v3 ad=2.08p pd=8.52u as=2.08p ps=8.52u w=8u l=0.28u
X114 VSS.t98 SXP.t13 BP.t6 VSS.t97 nfet_03v3 ad=2.08p pd=8.52u as=2.08p ps=8.52u w=8u l=0.28u
X115 VDD.t65 REGEN_CLK.t31 XP.t15 VDD.t46 pfet_03v3 ad=2.08p pd=8.52u as=2.08p ps=8.52u w=8u l=0.28u
X116 VDD.t21 BP.t19 OUTP.t6 VDD.t20 pfet_03v3 ad=2.08p pd=8.52u as=2.08p ps=8.52u w=8u l=0.28u
X117 NTAIL.t11 SENSE_BOOST_CLK.t0 VSS.t117 VSS.t59 nfet_03v3 ad=3.52p pd=16.88u as=2.08p ps=8.52u w=8u l=0.28u
X118 VDD.t68 REGEN_CLK.t15 XN.t20 VDD.t54 pfet_03v3 ad=2.08p pd=8.52u as=2.08p ps=8.52u w=8u l=0.28u
X119 VSS.t114 SENSE_BOOST_CLK.t3 NTAIL.t8 VSS.t53 nfet_03v3 ad=2.08p pd=8.52u as=2.08p ps=8.52u w=8u l=0.28u
X120 XP.t12 REGEN_CLK.t34 VDD.t61 VDD.t60 pfet_03v3 ad=2.08p pd=8.52u as=2.08p ps=8.52u w=8u l=0.28u
X121 XN.t23 REGEN_CLK.t12 VDD.t91 VDD.t90 pfet_03v3 ad=3.52p pd=16.88u as=2.08p ps=8.52u w=8u l=0.28u
X122 SA.t2 INP.t0 NTAIL.t2 VSS.t26 nfet_03v3 ad=3.52p pd=16.88u as=2.08p ps=8.52u w=8u l=0.28u
X123 XP.t18 REGEN_CLK.t28 VDD.t74 VDD.t73 pfet_03v3 ad=3.52p pd=16.88u as=2.08p ps=8.52u w=8u l=0.28u
X124 XN.t17 REGEN_CLK.t18 VDD.t84 VDD.t83 pfet_03v3 ad=2.08p pd=8.52u as=2.08p ps=8.52u w=8u l=0.28u
X125 VDD.t129 REGEN_CLKB.t15 VREGP.t0 VDD.t128 pfet_03v3 ad=2.08p pd=8.52u as=3.52p ps=16.88u w=8u l=0.28u
X126 VDD.t26 XP.t47 SXP.t4 VDD.t25 pfet_03v3 ad=2.08p pd=8.52u as=2.08p ps=8.52u w=8u l=0.28u
X127 OUTN.t12 BN.t10 VSS.t121 VSS.t120 nfet_03v3 ad=3.52p pd=16.88u as=2.08p ps=8.52u w=8u l=0.28u
X128 XP.t6 REGEN_CLK.t24 XN.t11 VDD.t50 pfet_03v3 ad=2.08p pd=8.52u as=2.08p ps=8.52u w=8u l=0.28u
X129 XP.t1 SB.t13 NREGEN.t4 VSS.t22 nfet_03v3 ad=2.08p pd=8.52u as=2.08p ps=8.52u w=8u l=0.28u
X130 SXP.t2 XP.t46 VDD.t17 VDD.t16 pfet_03v3 ad=2.08p pd=8.52u as=2.08p ps=8.52u w=8u l=0.28u
X131 VSS.t123 BN.t11 OUTN.t13 VSS.t122 nfet_03v3 ad=2.08p pd=8.52u as=2.08p ps=8.52u w=8u l=0.28u
X132 NREGEN.t12 REGEN_CLK.t4 VSS.t54 VSS.t53 nfet_03v3 ad=2.08p pd=8.52u as=2.08p ps=8.52u w=8u l=0.28u
X133 XP.t25 XN.t52 VREGP.t13 VDD.t104 pfet_03v3 ad=2.08p pd=8.52u as=2.08p ps=8.52u w=8u l=0.28u
X134 VDD.t119 XN.t45 SXN.t7 VDD.t118 pfet_03v3 ad=2.08p pd=8.52u as=2.08p ps=8.52u w=8u l=0.28u
X135 XN.t29 SA.t9 NREGEN.t28 VSS.t100 nfet_03v3 ad=2.08p pd=8.52u as=2.08p ps=8.52u w=8u l=0.28u
X136 VSS.t16 XP.t41 SXP.t3 VSS.t15 nfet_03v3 ad=2.08p pd=8.52u as=3.52p ps=16.88u w=8u l=0.28u
X137 VREGP.t14 XN.t51 XP.t27 VDD.t111 pfet_03v3 ad=2.08p pd=8.52u as=2.08p ps=8.52u w=8u l=0.28u
X138 VSS.t60 REGEN_CLK.t1 NREGEN.t15 VSS.t59 nfet_03v3 ad=2.08p pd=8.52u as=2.08p ps=8.52u w=8u l=0.28u
X139 XP.t31 XN.t36 NREGEN.t32 VSS.t108 nfet_03v3 ad=2.08p pd=8.52u as=2.08p ps=8.52u w=8u l=0.28u
X140 OUTN.t2 BN.t22 VDD.t101 VDD.t100 pfet_03v3 ad=2.08p pd=8.52u as=2.08p ps=8.52u w=8u l=0.28u
X141 XP.t16 REGEN_CLK.t30 VDD.t70 VDD.t69 pfet_03v3 ad=2.08p pd=8.52u as=2.08p ps=8.52u w=8u l=0.28u
X142 SXP.t9 XP.t40 VSS.t74 VSS.t73 nfet_03v3 ad=2.08p pd=8.52u as=2.08p ps=8.52u w=8u l=0.28u
X143 XN.t19 REGEN_CLK.t16 VDD.t87 VDD.t52 pfet_03v3 ad=2.08p pd=8.52u as=2.08p ps=8.52u w=8u l=0.28u
X144 XN.t7 XP.t56 VREGN.t9 VDD.t39 pfet_03v3 ad=2.08p pd=8.52u as=2.08p ps=8.52u w=8u l=0.28u
X145 NTAIL.t5 SENSE_CLK.t0 VSS.t46 VSS.t45 nfet_03v3 ad=3.52p pd=16.88u as=2.08p ps=8.52u w=8u l=0.28u
X146 NTAIL.t9 SENSE_BOOST_CLK.t2 VSS.t115 VSS.t55 nfet_03v3 ad=2.08p pd=8.52u as=2.08p ps=8.52u w=8u l=0.28u
X147 VSS.t11 BP.t15 OUTP.t4 VSS.t10 nfet_03v3 ad=2.08p pd=8.52u as=3.52p ps=16.88u w=8u l=0.28u
X148 VDD.t103 BN.t23 OUTN.t3 VDD.t102 pfet_03v3 ad=2.08p pd=8.52u as=3.52p ps=16.88u w=8u l=0.28u
X149 VDD.t145 REGEN_CLKB.t7 VREGN.t0 VDD.t144 pfet_03v3 ad=2.08p pd=8.52u as=3.52p ps=16.88u w=8u l=0.28u
X150 VDD.t64 REGEN_CLK.t33 XP.t13 VDD.t63 pfet_03v3 ad=2.08p pd=8.52u as=2.08p ps=8.52u w=8u l=0.28u
X151 VSS.t5 SXN.t15 BN.t0 VSS.t4 nfet_03v3 ad=2.08p pd=8.52u as=2.08p ps=8.52u w=8u l=0.28u
X152 VSS.t68 XN.t39 SXN.t4 VSS.t67 nfet_03v3 ad=2.08p pd=8.52u as=2.08p ps=8.52u w=8u l=0.28u
X153 VDD.t89 REGEN_CLK.t13 XN.t22 VDD.t88 pfet_03v3 ad=2.08p pd=8.52u as=2.08p ps=8.52u w=8u l=0.28u
X154 VSS.t112 SENSE_BOOST_CLK.t5 NTAIL.t6 VSS.t51 nfet_03v3 ad=2.08p pd=8.52u as=3.52p ps=16.88u w=8u l=0.28u
X155 VSS.t30 SXN.t13 BN.t2 VSS.t29 nfet_03v3 ad=2.08p pd=8.52u as=2.08p ps=8.52u w=8u l=0.28u
X156 NTAIL.t3 INP.t1 SA.t1 VSS.t25 nfet_03v3 ad=2.08p pd=8.52u as=3.52p ps=16.88u w=8u l=0.28u
X157 VDD.t115 BN.t17 OUTN.t7 VDD.t114 pfet_03v3 ad=2.08p pd=8.52u as=2.08p ps=8.52u w=8u l=0.28u
X158 VREGN.t8 XP.t57 XN.t2 VDD.t14 pfet_03v3 ad=2.08p pd=8.52u as=3.52p ps=16.88u w=8u l=0.28u
X159 NREGEN.t0 XP.t37 XN.t0 VSS.t2 nfet_03v3 ad=2.08p pd=8.52u as=3.52p ps=16.88u w=8u l=0.28u
X160 VREGN.t14 XP.t51 XN.t3 VDD.t15 pfet_03v3 ad=2.08p pd=8.52u as=2.08p ps=8.52u w=8u l=0.28u
X161 BN.t6 SXN.t20 VDD.t125 VDD.t124 pfet_03v3 ad=3.52p pd=16.88u as=2.08p ps=8.52u w=8u l=0.28u
X162 XP.t8 REGEN_CLK.t22 XN.t13 VDD.t78 pfet_03v3 ad=2.08p pd=8.52u as=2.08p ps=8.52u w=8u l=0.28u
X163 NREGEN.t23 SB.t14 XP.t21 VSS.t75 nfet_03v3 ad=2.08p pd=8.52u as=3.52p ps=16.88u w=8u l=0.28u
X164 BP.t7 SXP.t12 VSS.t96 VSS.t95 nfet_03v3 ad=3.52p pd=16.88u as=2.08p ps=8.52u w=8u l=0.28u
X165 OUTP.t5 BP.t18 VDD.t19 VDD.t18 pfet_03v3 ad=2.08p pd=8.52u as=2.08p ps=8.52u w=8u l=0.28u
X166 BN.t3 SXN.t14 VSS.t32 VSS.t31 nfet_03v3 ad=2.08p pd=8.52u as=2.08p ps=8.52u w=8u l=0.28u
X167 OUTN.t10 BN.t18 VDD.t164 VDD.t163 pfet_03v3 ad=2.08p pd=8.52u as=2.08p ps=8.52u w=8u l=0.28u
X168 NTAIL.t0 INN.t1 SB.t1 VSS.t0 nfet_03v3 ad=2.08p pd=8.52u as=3.52p ps=16.88u w=8u l=0.28u
X169 VSS.t48 REGEN_CLK.t5 NREGEN.t11 VSS.t47 nfet_03v3 ad=2.08p pd=8.52u as=2.08p ps=8.52u w=8u l=0.28u
X170 OUTN.t6 BN.t16 VDD.t113 VDD.t112 pfet_03v3 ad=3.52p pd=16.88u as=2.08p ps=8.52u w=8u l=0.28u
X171 XN.t28 XP.t52 VREGN.t13 VDD.t162 pfet_03v3 ad=2.08p pd=8.52u as=2.08p ps=8.52u w=8u l=0.28u
X172 XN.t8 XP.t50 VREGN.t15 VDD.t40 pfet_03v3 ad=3.52p pd=16.88u as=2.08p ps=8.52u w=8u l=0.28u
X173 VDD.t3 BP.t17 OUTP.t1 VDD.t2 pfet_03v3 ad=2.08p pd=8.52u as=2.08p ps=8.52u w=8u l=0.28u
X174 NREGEN.t31 SA.t8 XN.t31 VSS.t103 nfet_03v3 ad=2.08p pd=8.52u as=2.08p ps=8.52u w=8u l=0.28u
X175 XP.t23 SB.t7 NREGEN.t29 VSS.t101 nfet_03v3 ad=3.52p pd=16.88u as=2.08p ps=8.52u w=8u l=0.28u
X176 VSS.t94 SXP.t19 BP.t0 VSS.t93 nfet_03v3 ad=2.08p pd=8.52u as=3.52p ps=16.88u w=8u l=0.28u
X177 XP.t4 REGEN_CLK.t26 XN.t25 VDD.t76 pfet_03v3 ad=2.08p pd=8.52u as=2.08p ps=8.52u w=8u l=0.28u
X178 NREGEN.t5 SB.t10 XP.t2 VSS.t23 nfet_03v3 ad=2.08p pd=8.52u as=2.08p ps=8.52u w=8u l=0.28u
X179 NREGEN.t14 REGEN_CLK.t2 VSS.t58 VSS.t57 nfet_03v3 ad=2.08p pd=8.52u as=2.08p ps=8.52u w=8u l=0.28u
X180 NREGEN.t26 XN.t37 XP.t30 VSS.t86 nfet_03v3 ad=2.08p pd=8.52u as=3.52p ps=16.88u w=8u l=0.28u
X181 BP.t3 SXP.t16 VSS.t40 VSS.t39 nfet_03v3 ad=2.08p pd=8.52u as=2.08p ps=8.52u w=8u l=0.28u
R0 SENSE_BOOST_CLK.n3 SENSE_BOOST_CLK.t5 113.632
R1 SENSE_BOOST_CLK.n0 SENSE_BOOST_CLK.t0 109.174
R2 SENSE_BOOST_CLK.n7 SENSE_BOOST_CLK.t1 109.174
R3 SENSE_BOOST_CLK.n6 SENSE_BOOST_CLK.t2 109.174
R4 SENSE_BOOST_CLK.n5 SENSE_BOOST_CLK.t3 109.174
R5 SENSE_BOOST_CLK.n2 SENSE_BOOST_CLK.t4 109.174
R6 SENSE_BOOST_CLK SENSE_BOOST_CLK.n9 34.2009
R7 SENSE_BOOST_CLK.n9 SENSE_BOOST_CLK.n0 18.5636
R8 SENSE_BOOST_CLK.n8 SENSE_BOOST_CLK.n7 18.4942
R9 SENSE_BOOST_CLK.n6 SENSE_BOOST_CLK.n1 18.4942
R10 SENSE_BOOST_CLK.n5 SENSE_BOOST_CLK.n4 18.4942
R11 SENSE_BOOST_CLK.n7 SENSE_BOOST_CLK.n0 11.6805
R12 SENSE_BOOST_CLK.n7 SENSE_BOOST_CLK.n6 11.6805
R13 SENSE_BOOST_CLK.n6 SENSE_BOOST_CLK.n5 11.6805
R14 SENSE_BOOST_CLK.n5 SENSE_BOOST_CLK.n2 11.6805
R15 SENSE_BOOST_CLK.n4 SENSE_BOOST_CLK.n3 7.17687
R16 SENSE_BOOST_CLK.n3 SENSE_BOOST_CLK.n2 4.42851
R17 SENSE_BOOST_CLK.n4 SENSE_BOOST_CLK.n1 0.1205
R18 SENSE_BOOST_CLK.n8 SENSE_BOOST_CLK.n1 0.1205
R19 SENSE_BOOST_CLK.n9 SENSE_BOOST_CLK.n8 0.0485
R20 INN.n0 INN.t1 113.618
R21 INN.n0 INN.t0 113.618
R22 INN INN.n0 51.1947
R23 INP.n0 INP.t1 113.618
R24 INP.n0 INP.t0 113.618
R25 INP INP.n0 46.1665
R26 OUTN OUTN.n12 11.3292
R27 OUTN.n12 OUTN.n11 9.42986
R28 OUTN.n12 OUTN.n6 7.01407
R29 OUTN.n8 OUTN.t12 5.7796
R30 OUTN.n1 OUTN.t6 5.73764
R31 OUTN.n5 OUTN.t3 5.73764
R32 OUTN.n11 OUTN.t9 5.59012
R33 OUTN.n8 OUTN.n7 5.38537
R34 OUTN.n10 OUTN.n9 5.38537
R35 OUTN.n1 OUTN.n0 5.32067
R36 OUTN.n3 OUTN.n2 5.32067
R37 OUTN.n5 OUTN.n4 5.32067
R38 OUTN.n0 OUTN.t10 0.228
R39 OUTN.n0 OUTN.t7 0.228
R40 OUTN.n2 OUTN.t4 0.228
R41 OUTN.n2 OUTN.t11 0.228
R42 OUTN.n4 OUTN.t2 0.228
R43 OUTN.n4 OUTN.t5 0.228
R44 OUTN.n7 OUTN.t0 0.20525
R45 OUTN.n7 OUTN.t13 0.20525
R46 OUTN.n9 OUTN.t8 0.20525
R47 OUTN.n9 OUTN.t1 0.20525
R48 OUTN.n11 OUTN.n10 0.189974
R49 OUTN.n10 OUTN.n8 0.189974
R50 OUTN.n3 OUTN.n1 0.189974
R51 OUTN.n6 OUTN.n5 0.0952368
R52 OUTN.n6 OUTN.n3 0.0952368
R53 OUTP OUTP.n12 11.0162
R54 OUTP.n12 OUTP.n11 8.81407
R55 OUTP.n12 OUTP.n6 7.46407
R56 OUTP.n8 OUTP.t4 5.7796
R57 OUTP.n1 OUTP.t0 5.73764
R58 OUTP.n5 OUTP.t13 5.73764
R59 OUTP.n11 OUTP.t7 5.61381
R60 OUTP.n10 OUTP.n9 5.38537
R61 OUTP.n8 OUTP.n7 5.38537
R62 OUTP.n1 OUTP.n0 5.32067
R63 OUTP.n3 OUTP.n2 5.32067
R64 OUTP.n5 OUTP.n4 5.32067
R65 OUTP.n0 OUTP.t5 0.228
R66 OUTP.n0 OUTP.t1 0.228
R67 OUTP.n2 OUTP.t9 0.228
R68 OUTP.n2 OUTP.t6 0.228
R69 OUTP.n4 OUTP.t2 0.228
R70 OUTP.n4 OUTP.t10 0.228
R71 OUTP.n9 OUTP.t11 0.20525
R72 OUTP.n9 OUTP.t8 0.20525
R73 OUTP.n7 OUTP.t3 0.20525
R74 OUTP.n7 OUTP.t12 0.20525
R75 OUTP.n10 OUTP.n8 0.189974
R76 OUTP.n3 OUTP.n1 0.189974
R77 OUTP.n11 OUTP.n10 0.166289
R78 OUTP.n6 OUTP.n5 0.0952368
R79 OUTP.n6 OUTP.n3 0.0952368
R80 SENSE_CLK.n0 SENSE_CLK.t2 113.632
R81 SENSE_CLK.n1 SENSE_CLK.t5 113.632
R82 SENSE_CLK.n5 SENSE_CLK.t6 113.632
R83 SENSE_CLK.n3 SENSE_CLK.t0 113.618
R84 SENSE_CLK.n3 SENSE_CLK.t1 113.618
R85 SENSE_CLK.n0 SENSE_CLK.t3 113.603
R86 SENSE_CLK.n1 SENSE_CLK.t4 113.603
R87 SENSE_CLK.n5 SENSE_CLK.t7 113.603
R88 SENSE_CLK.n6 SENSE_CLK.n5 35.4506
R89 SENSE_CLK.n4 SENSE_CLK.n2 22.7641
R90 SENSE_CLK SENSE_CLK.n6 18.6466
R91 SENSE_CLK.n4 SENSE_CLK.n3 16.0613
R92 SENSE_CLK.n6 SENSE_CLK.n4 9.38566
R93 SENSE_CLK.n2 SENSE_CLK.n0 7.88487
R94 SENSE_CLK.n2 SENSE_CLK.n1 7.88487
R95 REGEN_CLK.t12 REGEN_CLK.n72 127.788
R96 REGEN_CLK.t35 REGEN_CLK.n32 127.788
R97 REGEN_CLK.t20 REGEN_CLK.n11 127.788
R98 REGEN_CLK.t19 REGEN_CLK.n61 127.668
R99 REGEN_CLK.n72 REGEN_CLK.t13 127.668
R100 REGEN_CLK.n71 REGEN_CLK.t14 127.668
R101 REGEN_CLK.n70 REGEN_CLK.t15 127.668
R102 REGEN_CLK.n69 REGEN_CLK.t16 127.668
R103 REGEN_CLK.n68 REGEN_CLK.t17 127.668
R104 REGEN_CLK.n67 REGEN_CLK.t18 127.668
R105 REGEN_CLK.t27 REGEN_CLK.n20 127.668
R106 REGEN_CLK.t28 REGEN_CLK.n41 127.668
R107 REGEN_CLK.n40 REGEN_CLK.t29 127.668
R108 REGEN_CLK.n32 REGEN_CLK.t34 127.668
R109 REGEN_CLK.n31 REGEN_CLK.t33 127.668
R110 REGEN_CLK.n30 REGEN_CLK.t32 127.668
R111 REGEN_CLK.t31 REGEN_CLK.n25 127.668
R112 REGEN_CLK.n39 REGEN_CLK.t30 127.668
R113 REGEN_CLK.n11 REGEN_CLK.t21 127.668
R114 REGEN_CLK.n10 REGEN_CLK.t22 127.668
R115 REGEN_CLK.n9 REGEN_CLK.t23 127.668
R116 REGEN_CLK.t24 REGEN_CLK.n4 127.668
R117 REGEN_CLK.n18 REGEN_CLK.t25 127.668
R118 REGEN_CLK.n19 REGEN_CLK.t26 127.668
R119 REGEN_CLK.n84 REGEN_CLK.t8 113.632
R120 REGEN_CLK.n0 REGEN_CLK.t10 113.632
R121 REGEN_CLK.n73 REGEN_CLK.t12 113.632
R122 REGEN_CLK.n48 REGEN_CLK.t7 113.632
R123 REGEN_CLK.n52 REGEN_CLK.t0 113.632
R124 REGEN_CLK.n33 REGEN_CLK.t35 113.632
R125 REGEN_CLK.n12 REGEN_CLK.t20 113.632
R126 REGEN_CLK.n84 REGEN_CLK.t9 113.603
R127 REGEN_CLK.n0 REGEN_CLK.t11 113.603
R128 REGEN_CLK.n80 REGEN_CLK.t19 109.174
R129 REGEN_CLK.n74 REGEN_CLK.t13 109.174
R130 REGEN_CLK.n75 REGEN_CLK.t14 109.174
R131 REGEN_CLK.n76 REGEN_CLK.t15 109.174
R132 REGEN_CLK.n77 REGEN_CLK.t16 109.174
R133 REGEN_CLK.n78 REGEN_CLK.t17 109.174
R134 REGEN_CLK.n79 REGEN_CLK.t18 109.174
R135 REGEN_CLK.n55 REGEN_CLK.t3 109.174
R136 REGEN_CLK.n56 REGEN_CLK.t4 109.174
R137 REGEN_CLK.n49 REGEN_CLK.t6 109.174
R138 REGEN_CLK.n50 REGEN_CLK.t5 109.174
R139 REGEN_CLK.n54 REGEN_CLK.t2 109.174
R140 REGEN_CLK.n51 REGEN_CLK.t1 109.174
R141 REGEN_CLK.n21 REGEN_CLK.t27 109.174
R142 REGEN_CLK.n42 REGEN_CLK.t28 109.174
R143 REGEN_CLK.t29 REGEN_CLK.n24 109.174
R144 REGEN_CLK.n34 REGEN_CLK.t34 109.174
R145 REGEN_CLK.n35 REGEN_CLK.t33 109.174
R146 REGEN_CLK.n36 REGEN_CLK.t32 109.174
R147 REGEN_CLK.n37 REGEN_CLK.t31 109.174
R148 REGEN_CLK.t30 REGEN_CLK.n38 109.174
R149 REGEN_CLK.n13 REGEN_CLK.t21 109.174
R150 REGEN_CLK.n14 REGEN_CLK.t22 109.174
R151 REGEN_CLK.n15 REGEN_CLK.t23 109.174
R152 REGEN_CLK.n16 REGEN_CLK.t24 109.174
R153 REGEN_CLK.t25 REGEN_CLK.n17 109.174
R154 REGEN_CLK.t26 REGEN_CLK.n3 109.174
R155 REGEN_CLK.n60 REGEN_CLK.n0 27.7007
R156 REGEN_CLK.n85 REGEN_CLK.n84 22.692
R157 REGEN_CLK.n59 REGEN_CLK.n58 20.0962
R158 REGEN_CLK.n81 REGEN_CLK.n80 18.4942
R159 REGEN_CLK.n75 REGEN_CLK.n66 18.4942
R160 REGEN_CLK.n76 REGEN_CLK.n65 18.4942
R161 REGEN_CLK.n77 REGEN_CLK.n64 18.4942
R162 REGEN_CLK.n78 REGEN_CLK.n63 18.4942
R163 REGEN_CLK.n79 REGEN_CLK.n62 18.4942
R164 REGEN_CLK.n55 REGEN_CLK.n46 18.4942
R165 REGEN_CLK.n57 REGEN_CLK.n56 18.4942
R166 REGEN_CLK.n50 REGEN_CLK.n47 18.4942
R167 REGEN_CLK.n54 REGEN_CLK.n53 18.4942
R168 REGEN_CLK.n22 REGEN_CLK.n21 18.4942
R169 REGEN_CLK.n43 REGEN_CLK.n42 18.4942
R170 REGEN_CLK.n24 REGEN_CLK.n23 18.4942
R171 REGEN_CLK.n35 REGEN_CLK.n29 18.4942
R172 REGEN_CLK.n36 REGEN_CLK.n28 18.4942
R173 REGEN_CLK.n37 REGEN_CLK.n27 18.4942
R174 REGEN_CLK.n38 REGEN_CLK.n26 18.4942
R175 REGEN_CLK.n14 REGEN_CLK.n8 18.4942
R176 REGEN_CLK.n15 REGEN_CLK.n7 18.4942
R177 REGEN_CLK.n16 REGEN_CLK.n6 18.4942
R178 REGEN_CLK.n17 REGEN_CLK.n5 18.4942
R179 REGEN_CLK.n3 REGEN_CLK.n2 18.4942
R180 REGEN_CLK REGEN_CLK.n85 15.9857
R181 REGEN_CLK.n75 REGEN_CLK.n74 11.6805
R182 REGEN_CLK.n76 REGEN_CLK.n75 11.6805
R183 REGEN_CLK.n77 REGEN_CLK.n76 11.6805
R184 REGEN_CLK.n78 REGEN_CLK.n77 11.6805
R185 REGEN_CLK.n79 REGEN_CLK.n78 11.6805
R186 REGEN_CLK.n80 REGEN_CLK.n79 11.6805
R187 REGEN_CLK.n55 REGEN_CLK.n54 11.6805
R188 REGEN_CLK.n56 REGEN_CLK.n55 11.6805
R189 REGEN_CLK.n50 REGEN_CLK.n49 11.6805
R190 REGEN_CLK.n56 REGEN_CLK.n50 11.6805
R191 REGEN_CLK.n54 REGEN_CLK.n51 11.6805
R192 REGEN_CLK.n42 REGEN_CLK.n24 11.6805
R193 REGEN_CLK.n35 REGEN_CLK.n34 11.6805
R194 REGEN_CLK.n36 REGEN_CLK.n35 11.6805
R195 REGEN_CLK.n37 REGEN_CLK.n36 11.6805
R196 REGEN_CLK.n38 REGEN_CLK.n37 11.6805
R197 REGEN_CLK.n38 REGEN_CLK.n24 11.6805
R198 REGEN_CLK.n14 REGEN_CLK.n13 11.6805
R199 REGEN_CLK.n15 REGEN_CLK.n14 11.6805
R200 REGEN_CLK.n16 REGEN_CLK.n15 11.6805
R201 REGEN_CLK.n17 REGEN_CLK.n16 11.6805
R202 REGEN_CLK.n17 REGEN_CLK.n3 11.6805
R203 REGEN_CLK.n21 REGEN_CLK.n3 11.6805
R204 REGEN_CLK.n82 REGEN_CLK.n61 10.8876
R205 REGEN_CLK.n45 REGEN_CLK.n1 10.8396
R206 REGEN_CLK.n83 REGEN_CLK.n82 10.3248
R207 REGEN_CLK.n82 REGEN_CLK.n81 9.0485
R208 REGEN_CLK.n45 REGEN_CLK.n44 9.0005
R209 REGEN_CLK.n73 REGEN_CLK.n66 7.17687
R210 REGEN_CLK.n53 REGEN_CLK.n52 7.17687
R211 REGEN_CLK.n48 REGEN_CLK.n47 7.17687
R212 REGEN_CLK.n33 REGEN_CLK.n29 7.17687
R213 REGEN_CLK.n12 REGEN_CLK.n8 7.17687
R214 REGEN_CLK.n59 REGEN_CLK.n45 5.82479
R215 REGEN_CLK.n60 REGEN_CLK.n59 4.5005
R216 REGEN_CLK.n74 REGEN_CLK.n73 4.42851
R217 REGEN_CLK.n49 REGEN_CLK.n48 4.42851
R218 REGEN_CLK.n52 REGEN_CLK.n51 4.42851
R219 REGEN_CLK.n34 REGEN_CLK.n33 4.42851
R220 REGEN_CLK.n13 REGEN_CLK.n12 4.42851
R221 REGEN_CLK.n85 REGEN_CLK.n83 3.83528
R222 REGEN_CLK.n83 REGEN_CLK.n60 2.89615
R223 REGEN_CLK.n44 REGEN_CLK.n22 0.4685
R224 REGEN_CLK.n20 REGEN_CLK.n1 0.4685
R225 REGEN_CLK.n41 REGEN_CLK.n1 0.4685
R226 REGEN_CLK.n44 REGEN_CLK.n43 0.4685
R227 REGEN_CLK.n81 REGEN_CLK.n62 0.1205
R228 REGEN_CLK.n63 REGEN_CLK.n62 0.1205
R229 REGEN_CLK.n64 REGEN_CLK.n63 0.1205
R230 REGEN_CLK.n65 REGEN_CLK.n64 0.1205
R231 REGEN_CLK.n66 REGEN_CLK.n65 0.1205
R232 REGEN_CLK.n67 REGEN_CLK.n61 0.1205
R233 REGEN_CLK.n68 REGEN_CLK.n67 0.1205
R234 REGEN_CLK.n69 REGEN_CLK.n68 0.1205
R235 REGEN_CLK.n70 REGEN_CLK.n69 0.1205
R236 REGEN_CLK.n71 REGEN_CLK.n70 0.1205
R237 REGEN_CLK.n72 REGEN_CLK.n71 0.1205
R238 REGEN_CLK.n53 REGEN_CLK.n46 0.1205
R239 REGEN_CLK.n57 REGEN_CLK.n47 0.1205
R240 REGEN_CLK.n22 REGEN_CLK.n2 0.1205
R241 REGEN_CLK.n5 REGEN_CLK.n2 0.1205
R242 REGEN_CLK.n6 REGEN_CLK.n5 0.1205
R243 REGEN_CLK.n7 REGEN_CLK.n6 0.1205
R244 REGEN_CLK.n8 REGEN_CLK.n7 0.1205
R245 REGEN_CLK.n20 REGEN_CLK.n19 0.1205
R246 REGEN_CLK.n19 REGEN_CLK.n18 0.1205
R247 REGEN_CLK.n18 REGEN_CLK.n4 0.1205
R248 REGEN_CLK.n9 REGEN_CLK.n4 0.1205
R249 REGEN_CLK.n10 REGEN_CLK.n9 0.1205
R250 REGEN_CLK.n11 REGEN_CLK.n10 0.1205
R251 REGEN_CLK.n32 REGEN_CLK.n31 0.1205
R252 REGEN_CLK.n31 REGEN_CLK.n30 0.1205
R253 REGEN_CLK.n30 REGEN_CLK.n25 0.1205
R254 REGEN_CLK.n39 REGEN_CLK.n25 0.1205
R255 REGEN_CLK.n40 REGEN_CLK.n39 0.1205
R256 REGEN_CLK.n41 REGEN_CLK.n40 0.1205
R257 REGEN_CLK.n29 REGEN_CLK.n28 0.1205
R258 REGEN_CLK.n28 REGEN_CLK.n27 0.1205
R259 REGEN_CLK.n27 REGEN_CLK.n26 0.1205
R260 REGEN_CLK.n26 REGEN_CLK.n23 0.1205
R261 REGEN_CLK.n43 REGEN_CLK.n23 0.1205
R262 REGEN_CLK.n58 REGEN_CLK.n46 0.0485
R263 REGEN_CLK.n58 REGEN_CLK.n57 0.0485
R264 REGEN_CLKB.t7 REGEN_CLKB.n32 127.788
R265 REGEN_CLKB.n16 REGEN_CLKB.t15 127.788
R266 REGEN_CLKB.t8 REGEN_CLKB.n7 127.788
R267 REGEN_CLKB.t0 REGEN_CLKB.n21 127.737
R268 REGEN_CLKB.n32 REGEN_CLKB.t6 127.668
R269 REGEN_CLKB.n31 REGEN_CLKB.t5 127.668
R270 REGEN_CLKB.n30 REGEN_CLKB.t4 127.668
R271 REGEN_CLKB.n29 REGEN_CLKB.t3 127.668
R272 REGEN_CLKB.n28 REGEN_CLKB.t2 127.668
R273 REGEN_CLKB.n27 REGEN_CLKB.t1 127.668
R274 REGEN_CLKB.t13 REGEN_CLKB.n14 127.668
R275 REGEN_CLKB.t14 REGEN_CLKB.n16 127.668
R276 REGEN_CLKB.n7 REGEN_CLKB.t9 127.668
R277 REGEN_CLKB.t10 REGEN_CLKB.n3 127.668
R278 REGEN_CLKB.n12 REGEN_CLKB.t11 127.668
R279 REGEN_CLKB.n13 REGEN_CLKB.t12 127.668
R280 REGEN_CLKB.n33 REGEN_CLKB.t7 113.632
R281 REGEN_CLKB.n18 REGEN_CLKB.t15 113.632
R282 REGEN_CLKB.n8 REGEN_CLKB.t8 113.632
R283 REGEN_CLKB.n22 REGEN_CLKB.t0 109.174
R284 REGEN_CLKB.t6 REGEN_CLKB.n26 109.174
R285 REGEN_CLKB.n35 REGEN_CLKB.t5 109.174
R286 REGEN_CLKB.n36 REGEN_CLKB.t4 109.174
R287 REGEN_CLKB.n37 REGEN_CLKB.t3 109.174
R288 REGEN_CLKB.n38 REGEN_CLKB.t2 109.174
R289 REGEN_CLKB.n39 REGEN_CLKB.t1 109.174
R290 REGEN_CLKB.n15 REGEN_CLKB.t13 109.174
R291 REGEN_CLKB.n17 REGEN_CLKB.t14 109.174
R292 REGEN_CLKB.n9 REGEN_CLKB.t9 109.174
R293 REGEN_CLKB.n10 REGEN_CLKB.t10 109.174
R294 REGEN_CLKB.t11 REGEN_CLKB.n11 109.174
R295 REGEN_CLKB.t12 REGEN_CLKB.n2 109.174
R296 REGEN_CLKB.n43 REGEN_CLKB.n20 24.2273
R297 REGEN_CLKB.n41 REGEN_CLKB.n22 18.5636
R298 REGEN_CLKB.n35 REGEN_CLKB.n34 18.4942
R299 REGEN_CLKB.n36 REGEN_CLKB.n25 18.4942
R300 REGEN_CLKB.n37 REGEN_CLKB.n24 18.4942
R301 REGEN_CLKB.n38 REGEN_CLKB.n23 18.4942
R302 REGEN_CLKB.n40 REGEN_CLKB.n39 18.4942
R303 REGEN_CLKB.n15 REGEN_CLKB.n1 18.4942
R304 REGEN_CLKB.n10 REGEN_CLKB.n6 18.4942
R305 REGEN_CLKB.n11 REGEN_CLKB.n5 18.4942
R306 REGEN_CLKB.n4 REGEN_CLKB.n2 18.4942
R307 REGEN_CLKB REGEN_CLKB.n43 16.7683
R308 REGEN_CLKB.n43 REGEN_CLKB.n42 14.0534
R309 REGEN_CLKB.n36 REGEN_CLKB.n35 11.6805
R310 REGEN_CLKB.n35 REGEN_CLKB.n26 11.6805
R311 REGEN_CLKB.n37 REGEN_CLKB.n36 11.6805
R312 REGEN_CLKB.n38 REGEN_CLKB.n37 11.6805
R313 REGEN_CLKB.n39 REGEN_CLKB.n38 11.6805
R314 REGEN_CLKB.n39 REGEN_CLKB.n22 11.6805
R315 REGEN_CLKB.n17 REGEN_CLKB.n15 11.6805
R316 REGEN_CLKB.n10 REGEN_CLKB.n9 11.6805
R317 REGEN_CLKB.n11 REGEN_CLKB.n10 11.6805
R318 REGEN_CLKB.n11 REGEN_CLKB.n2 11.6805
R319 REGEN_CLKB.n15 REGEN_CLKB.n2 11.6805
R320 REGEN_CLKB.n42 REGEN_CLKB.n21 10.8396
R321 REGEN_CLKB.n20 REGEN_CLKB.n0 10.8396
R322 REGEN_CLKB.n42 REGEN_CLKB.n41 9.0005
R323 REGEN_CLKB.n20 REGEN_CLKB.n19 9.0005
R324 REGEN_CLKB.n34 REGEN_CLKB.n33 7.17687
R325 REGEN_CLKB.n8 REGEN_CLKB.n6 7.17687
R326 REGEN_CLKB.n19 REGEN_CLKB.n18 7.10487
R327 REGEN_CLKB.n33 REGEN_CLKB.n26 4.42851
R328 REGEN_CLKB.n18 REGEN_CLKB.n17 4.42851
R329 REGEN_CLKB.n9 REGEN_CLKB.n8 4.42851
R330 REGEN_CLKB.n32 REGEN_CLKB.n31 0.1205
R331 REGEN_CLKB.n31 REGEN_CLKB.n30 0.1205
R332 REGEN_CLKB.n30 REGEN_CLKB.n29 0.1205
R333 REGEN_CLKB.n29 REGEN_CLKB.n28 0.1205
R334 REGEN_CLKB.n28 REGEN_CLKB.n27 0.1205
R335 REGEN_CLKB.n34 REGEN_CLKB.n25 0.1205
R336 REGEN_CLKB.n25 REGEN_CLKB.n24 0.1205
R337 REGEN_CLKB.n24 REGEN_CLKB.n23 0.1205
R338 REGEN_CLKB.n40 REGEN_CLKB.n23 0.1205
R339 REGEN_CLKB.n4 REGEN_CLKB.n1 0.1205
R340 REGEN_CLKB.n5 REGEN_CLKB.n4 0.1205
R341 REGEN_CLKB.n6 REGEN_CLKB.n5 0.1205
R342 REGEN_CLKB.n14 REGEN_CLKB.n13 0.1205
R343 REGEN_CLKB.n13 REGEN_CLKB.n12 0.1205
R344 REGEN_CLKB.n12 REGEN_CLKB.n3 0.1205
R345 REGEN_CLKB.n7 REGEN_CLKB.n3 0.1205
R346 REGEN_CLKB.n27 REGEN_CLKB.n21 0.0485
R347 REGEN_CLKB.n41 REGEN_CLKB.n40 0.0485
R348 REGEN_CLKB.n19 REGEN_CLKB.n1 0.0485
R349 REGEN_CLKB.n14 REGEN_CLKB.n0 0.0485
R350 REGEN_CLKB.n16 REGEN_CLKB.n0 0.0485
R351 VDD.n66 VDD.n65 166.667
R352 VDD.n66 VDD.n9 166.667
R353 VDD.n39 VDD.n38 166.667
R354 VDD.n38 VDD.n22 166.667
R355 VDD.n65 VDD.t41 143.333
R356 VDD.t98 VDD.n22 143.333
R357 VDD.n76 VDD.n75 106.3
R358 VDD.n29 VDD.n28 106.3
R359 VDD.n62 VDD.t92 93.3338
R360 VDD.n40 VDD.t96 93.3338
R361 VDD.t0 VDD.n74 86.6672
R362 VDD.n30 VDD.t102 86.6672
R363 VDD.n76 VDD.n3 70.0005
R364 VDD.n73 VDD.n3 70.0005
R365 VDD.n73 VDD.n4 70.0005
R366 VDD.n67 VDD.n4 70.0005
R367 VDD.n67 VDD.n8 70.0005
R368 VDD.n60 VDD.n8 70.0005
R369 VDD.n60 VDD.n11 70.0005
R370 VDD.n54 VDD.n11 70.0005
R371 VDD.n54 VDD.n15 70.0005
R372 VDD.n51 VDD.n15 70.0005
R373 VDD.n51 VDD.n16 70.0005
R374 VDD.n45 VDD.n16 70.0005
R375 VDD.n45 VDD.n20 70.0005
R376 VDD.n37 VDD.n20 70.0005
R377 VDD.n37 VDD.n23 70.0005
R378 VDD.n31 VDD.n23 70.0005
R379 VDD.n31 VDD.n27 70.0005
R380 VDD.n28 VDD.n27 70.0005
R381 VDD.n62 VDD.n9 66.6672
R382 VDD.n40 VDD.n39 66.6672
R383 VDD.n75 VDD.t160 53.3338
R384 VDD.t73 VDD.t173 53.3338
R385 VDD.t173 VDD.t75 53.3338
R386 VDD.t80 VDD.t171 53.3338
R387 VDD.t171 VDD.t81 53.3338
R388 VDD.t112 VDD.n29 53.3338
R389 VDD.n91 VDD.n90 24.4328
R390 VDD.n158 VDD.n157 24.4328
R391 VDD.n93 VDD.n92 22.1797
R392 VDD.n80 VDD.n79 22.1797
R393 VDD.n156 VDD.n155 19.4916
R394 VDD.n96 VDD.n94 19.4916
R395 VDD.n161 VDD.n159 19.0179
R396 VDD.n167 VDD.n166 19.0179
R397 VDD.n78 VDD.n77 18.1338
R398 VDD.n2 VDD.n1 18.0005
R399 VDD.n72 VDD.n71 18.0005
R400 VDD.n70 VDD.n5 18.0005
R401 VDD.n69 VDD.n68 18.0005
R402 VDD.n7 VDD.n6 18.0005
R403 VDD.n59 VDD.n58 18.0005
R404 VDD.n57 VDD.n12 18.0005
R405 VDD.n56 VDD.n55 18.0005
R406 VDD.n14 VDD.n13 18.0005
R407 VDD.n50 VDD.n49 18.0005
R408 VDD.n48 VDD.n17 18.0005
R409 VDD.n47 VDD.n46 18.0005
R410 VDD.n19 VDD.n18 18.0005
R411 VDD.n36 VDD.n35 18.0005
R412 VDD.n34 VDD.n24 18.0005
R413 VDD.n33 VDD.n32 18.0005
R414 VDD.n29 VDD.n21 17.6849
R415 VDD.n22 VDD.n21 16.4218
R416 VDD.n41 VDD.n40 16.4218
R417 VDD.n43 VDD.n42 16.4218
R418 VDD.n53 VDD.n10 16.4218
R419 VDD.n63 VDD.n62 16.4218
R420 VDD.n65 VDD.n64 16.4218
R421 VDD.n75 VDD.n0 16.4218
R422 VDD.n123 VDD.n114 14.8005
R423 VDD.n136 VDD.n127 14.8005
R424 VDD.n116 VDD.n113 14.6065
R425 VDD.t160 VDD.t11 13.3338
R426 VDD.t11 VDD.t35 13.3338
R427 VDD.t35 VDD.t33 13.3338
R428 VDD.t33 VDD.t20 13.3338
R429 VDD.t20 VDD.t18 13.3338
R430 VDD.t18 VDD.t2 13.3338
R431 VDD.t2 VDD.t0 13.3338
R432 VDD.t41 VDD.t43 13.3338
R433 VDD.t25 VDD.t29 13.3338
R434 VDD.t16 VDD.t25 13.3338
R435 VDD.t140 VDD.t136 13.3338
R436 VDD.t142 VDD.t140 13.3338
R437 VDD.t146 VDD.t142 13.3338
R438 VDD.t22 VDD.t37 13.3338
R439 VDD.t4 VDD.t22 13.3338
R440 VDD.t13 VDD.t4 13.3338
R441 VDD.t38 VDD.t13 13.3338
R442 VDD.t104 VDD.t38 13.3338
R443 VDD.t111 VDD.t104 13.3338
R444 VDD.t167 VDD.t111 13.3338
R445 VDD.t60 VDD.t58 13.3338
R446 VDD.t63 VDD.t60 13.3338
R447 VDD.t48 VDD.t63 13.3338
R448 VDD.t69 VDD.t46 13.3338
R449 VDD.t71 VDD.t69 13.3338
R450 VDD.t71 VDD.t73 13.3338
R451 VDD.t75 VDD.t76 13.3338
R452 VDD.t76 VDD.t77 13.3338
R453 VDD.t77 VDD.t50 13.3338
R454 VDD.t51 VDD.t78 13.3338
R455 VDD.t78 VDD.t79 13.3338
R456 VDD.t79 VDD.t80 13.3338
R457 VDD.t81 VDD.t83 13.3338
R458 VDD.t83 VDD.t85 13.3338
R459 VDD.t52 VDD.t85 13.3338
R460 VDD.t66 VDD.t54 13.3338
R461 VDD.t88 VDD.t66 13.3338
R462 VDD.t90 VDD.t88 13.3338
R463 VDD.t39 VDD.t14 13.3338
R464 VDD.t45 VDD.t39 13.3338
R465 VDD.t175 VDD.t45 13.3338
R466 VDD.t170 VDD.t175 13.3338
R467 VDD.t162 VDD.t170 13.3338
R468 VDD.t15 VDD.t162 13.3338
R469 VDD.t40 VDD.t15 13.3338
R470 VDD.t130 VDD.t144 13.3338
R471 VDD.t148 VDD.t130 13.3338
R472 VDD.t150 VDD.t148 13.3338
R473 VDD.t23 VDD.t118 13.3338
R474 VDD.t5 VDD.t23 13.3338
R475 VDD.t124 VDD.t98 13.3338
R476 VDD.t102 VDD.t100 13.3338
R477 VDD.t100 VDD.t109 13.3338
R478 VDD.t109 VDD.t107 13.3338
R479 VDD.t107 VDD.t165 13.3338
R480 VDD.t165 VDD.t163 13.3338
R481 VDD.t163 VDD.t114 13.3338
R482 VDD.t114 VDD.t112 13.3338
R483 VDD.n140 VDD.n138 12.2524
R484 VDD.n149 VDD.n147 11.8107
R485 VDD.n112 VDD.n111 11.7788
R486 VDD.n103 VDD.n102 11.7396
R487 VDD.n91 VDD.n89 10.5755
R488 VDD.n124 VDD.t172 10.4271
R489 VDD.n128 VDD.t174 10.4271
R490 VDD.n74 VDD.t43 10.0005
R491 VDD.t29 VDD.t94 10.0005
R492 VDD.t128 VDD.t16 10.0005
R493 VDD.t132 VDD.t105 10.0005
R494 VDD.t134 VDD.t9 10.0005
R495 VDD.t138 VDD.t31 10.0005
R496 VDD.t136 VDD.t27 10.0005
R497 VDD.t116 VDD.t150 10.0005
R498 VDD.t120 VDD.t154 10.0005
R499 VDD.t126 VDD.t152 10.0005
R500 VDD.t168 VDD.t156 10.0005
R501 VDD.t118 VDD.t158 10.0005
R502 VDD.t56 VDD.t5 10.0005
R503 VDD.n30 VDD.t124 10.0005
R504 VDD.n137 VDD.n136 9.82224
R505 VDD.n33 VDD.n25 9.31191
R506 VDD.n103 VDD.n82 7.27876
R507 VDD.n125 VDD.n124 7.27876
R508 VDD.n128 VDD.n126 7.27876
R509 VDD.n147 VDD.n81 7.27876
R510 VDD.n135 VDD.n128 7.13872
R511 VDD.n28 VDD.n25 6.79358
R512 VDD.t92 VDD.n61 6.66717
R513 VDD.t37 VDD.t146 6.66717
R514 VDD.t58 VDD.t167 6.66717
R515 VDD.n53 VDD.t48 6.66717
R516 VDD.t46 VDD.n53 6.66717
R517 VDD.t50 VDD.n52 6.66717
R518 VDD.n52 VDD.t51 6.66717
R519 VDD.n43 VDD.t52 6.66717
R520 VDD.t54 VDD.n43 6.66717
R521 VDD.t14 VDD.t90 6.66717
R522 VDD.t144 VDD.t40 6.66717
R523 VDD.n44 VDD.t96 6.66717
R524 VDD.n77 VDD.n76 6.3005
R525 VDD.t11 VDD.n3 6.3005
R526 VDD.n3 VDD.n2 6.3005
R527 VDD.n74 VDD.n73 6.3005
R528 VDD.n73 VDD.n72 6.3005
R529 VDD.n65 VDD.n4 6.3005
R530 VDD.n5 VDD.n4 6.3005
R531 VDD.n67 VDD.n66 6.3005
R532 VDD.n68 VDD.n67 6.3005
R533 VDD.n9 VDD.n8 6.3005
R534 VDD.n8 VDD.n7 6.3005
R535 VDD.n61 VDD.n60 6.3005
R536 VDD.n60 VDD.n59 6.3005
R537 VDD.t22 VDD.n11 6.3005
R538 VDD.n12 VDD.n11 6.3005
R539 VDD.n54 VDD.t71 6.3005
R540 VDD.n55 VDD.n54 6.3005
R541 VDD.n52 VDD.n15 6.3005
R542 VDD.n15 VDD.n14 6.3005
R543 VDD.t83 VDD.n51 6.3005
R544 VDD.n51 VDD.n50 6.3005
R545 VDD.t15 VDD.n16 6.3005
R546 VDD.n17 VDD.n16 6.3005
R547 VDD.n45 VDD.n44 6.3005
R548 VDD.n46 VDD.n45 6.3005
R549 VDD.n39 VDD.n20 6.3005
R550 VDD.n20 VDD.n19 6.3005
R551 VDD.n38 VDD.n37 6.3005
R552 VDD.n37 VDD.n36 6.3005
R553 VDD.n23 VDD.n22 6.3005
R554 VDD.n24 VDD.n23 6.3005
R555 VDD.n31 VDD.n30 6.3005
R556 VDD.n32 VDD.n31 6.3005
R557 VDD.t114 VDD.n27 6.3005
R558 VDD.n27 VDD.n26 6.3005
R559 VDD.n168 VDD.n167 5.66103
R560 VDD.n86 VDD.n84 5.51014
R561 VDD.n108 VDD.n106 5.51014
R562 VDD.n101 VDD.n99 5.51014
R563 VDD.n131 VDD.n129 5.51014
R564 VDD.n145 VDD.n143 5.51014
R565 VDD.n164 VDD.n162 5.51014
R566 VDD.n89 VDD.n83 5.4159
R567 VDD.n88 VDD.n87 5.32067
R568 VDD.n86 VDD.n85 5.32067
R569 VDD.n105 VDD.n104 5.32067
R570 VDD.n110 VDD.n109 5.32067
R571 VDD.n108 VDD.n107 5.32067
R572 VDD.n96 VDD.n95 5.32067
R573 VDD.n98 VDD.n97 5.32067
R574 VDD.n101 VDD.n100 5.32067
R575 VDD.n116 VDD.n115 5.32067
R576 VDD.n118 VDD.n117 5.32067
R577 VDD.n120 VDD.n119 5.32067
R578 VDD.n122 VDD.n121 5.32067
R579 VDD.n135 VDD.n134 5.32067
R580 VDD.n133 VDD.n132 5.32067
R581 VDD.n131 VDD.n130 5.32067
R582 VDD.n149 VDD.n148 5.32067
R583 VDD.n151 VDD.n150 5.32067
R584 VDD.n153 VDD.n152 5.32067
R585 VDD.n155 VDD.n154 5.32067
R586 VDD.n140 VDD.n139 5.32067
R587 VDD.n142 VDD.n141 5.32067
R588 VDD.n145 VDD.n144 5.32067
R589 VDD.n161 VDD.n160 5.32067
R590 VDD.n166 VDD.n165 5.32067
R591 VDD.n164 VDD.n163 5.32067
R592 VDD.n105 VDD.n103 4.59524
R593 VDD.n123 VDD.n122 4.5005
R594 VDD.n136 VDD.n135 4.5005
R595 VDD.n147 VDD.n146 4.5005
R596 VDD.n94 VDD.n91 4.31103
R597 VDD.n158 VDD.n156 4.12155
R598 VDD.n61 VDD.t7 3.33383
R599 VDD.t94 VDD.t7 3.33383
R600 VDD.t105 VDD.t128 3.33383
R601 VDD.t9 VDD.t132 3.33383
R602 VDD.t31 VDD.t134 3.33383
R603 VDD.t27 VDD.t138 3.33383
R604 VDD.t154 VDD.t116 3.33383
R605 VDD.t152 VDD.t120 3.33383
R606 VDD.t156 VDD.t126 3.33383
R607 VDD.t158 VDD.t168 3.33383
R608 VDD.t122 VDD.t56 3.33383
R609 VDD.n44 VDD.t122 3.33383
R610 VDD.n124 VDD.n123 2.54398
R611 VDD.n126 VDD.n125 2.17945
R612 VDD.n64 VDD.n0 1.26366
R613 VDD.n64 VDD.n63 1.26366
R614 VDD.n63 VDD.n10 1.26366
R615 VDD.n42 VDD.n10 1.26366
R616 VDD.n42 VDD.n41 1.26366
R617 VDD.n41 VDD.n21 1.26366
R618 VDD.n113 VDD.n112 1.04261
R619 VDD.n77 VDD.n2 1.0005
R620 VDD.n72 VDD.n2 1.0005
R621 VDD.n72 VDD.n5 1.0005
R622 VDD.n68 VDD.n5 1.0005
R623 VDD.n68 VDD.n7 1.0005
R624 VDD.n59 VDD.n7 1.0005
R625 VDD.n59 VDD.n12 1.0005
R626 VDD.n55 VDD.n12 1.0005
R627 VDD.n55 VDD.n14 1.0005
R628 VDD.n50 VDD.n14 1.0005
R629 VDD.n50 VDD.n17 1.0005
R630 VDD.n46 VDD.n17 1.0005
R631 VDD.n46 VDD.n19 1.0005
R632 VDD.n36 VDD.n19 1.0005
R633 VDD.n36 VDD.n24 1.0005
R634 VDD.n32 VDD.n24 1.0005
R635 VDD.n32 VDD.n26 1.0005
R636 VDD.n138 VDD.n137 0.947868
R637 VDD.n159 VDD.n158 0.876816
R638 VDD.n125 VDD.n113 0.853132
R639 VDD.n138 VDD.n81 0.758395
R640 VDD.n156 VDD.n80 0.592605
R641 VDD.n81 VDD.n80 0.521553
R642 VDD.n93 VDD.n82 0.521553
R643 VDD.n26 VDD.n25 0.481712
R644 VDD.n71 VDD.n1 0.444944
R645 VDD.n71 VDD.n70 0.444944
R646 VDD.n70 VDD.n69 0.444944
R647 VDD.n69 VDD.n6 0.444944
R648 VDD.n58 VDD.n6 0.444944
R649 VDD.n58 VDD.n57 0.444944
R650 VDD.n57 VDD.n56 0.444944
R651 VDD.n56 VDD.n13 0.444944
R652 VDD.n49 VDD.n13 0.444944
R653 VDD.n49 VDD.n48 0.444944
R654 VDD.n48 VDD.n47 0.444944
R655 VDD.n47 VDD.n18 0.444944
R656 VDD.n35 VDD.n18 0.444944
R657 VDD.n35 VDD.n34 0.444944
R658 VDD.n34 VDD.n33 0.444944
R659 VDD.n78 VDD.n1 0.311611
R660 VDD VDD.n0 0.267342
R661 VDD.n83 VDD.t115 0.228
R662 VDD.n83 VDD.t113 0.228
R663 VDD.n87 VDD.t166 0.228
R664 VDD.n87 VDD.t164 0.228
R665 VDD.n85 VDD.t110 0.228
R666 VDD.n85 VDD.t108 0.228
R667 VDD.n84 VDD.t103 0.228
R668 VDD.n84 VDD.t101 0.228
R669 VDD.n90 VDD.t99 0.228
R670 VDD.n90 VDD.t125 0.228
R671 VDD.n104 VDD.t157 0.228
R672 VDD.n104 VDD.t159 0.228
R673 VDD.n109 VDD.t155 0.228
R674 VDD.n109 VDD.t153 0.228
R675 VDD.n107 VDD.t149 0.228
R676 VDD.n107 VDD.t151 0.228
R677 VDD.n106 VDD.t145 0.228
R678 VDD.n106 VDD.t131 0.228
R679 VDD.n95 VDD.t6 0.228
R680 VDD.n95 VDD.t123 0.228
R681 VDD.n97 VDD.t119 0.228
R682 VDD.n97 VDD.t24 0.228
R683 VDD.n100 VDD.t127 0.228
R684 VDD.n100 VDD.t169 0.228
R685 VDD.n99 VDD.t117 0.228
R686 VDD.n99 VDD.t121 0.228
R687 VDD.n92 VDD.t57 0.228
R688 VDD.n92 VDD.t97 0.228
R689 VDD.n115 VDD.t89 0.228
R690 VDD.n115 VDD.t91 0.228
R691 VDD.n117 VDD.t68 0.228
R692 VDD.n117 VDD.t67 0.228
R693 VDD.n119 VDD.t86 0.228
R694 VDD.n119 VDD.t87 0.228
R695 VDD.n114 VDD.t53 0.228
R696 VDD.n114 VDD.t55 0.228
R697 VDD.n121 VDD.t82 0.228
R698 VDD.n121 VDD.t84 0.228
R699 VDD.n127 VDD.t49 0.228
R700 VDD.n127 VDD.t47 0.228
R701 VDD.n134 VDD.t72 0.228
R702 VDD.n134 VDD.t74 0.228
R703 VDD.n132 VDD.t65 0.228
R704 VDD.n132 VDD.t70 0.228
R705 VDD.n130 VDD.t64 0.228
R706 VDD.n130 VDD.t62 0.228
R707 VDD.n129 VDD.t59 0.228
R708 VDD.n129 VDD.t61 0.228
R709 VDD.n148 VDD.t32 0.228
R710 VDD.n148 VDD.t28 0.228
R711 VDD.n150 VDD.t106 0.228
R712 VDD.n150 VDD.t10 0.228
R713 VDD.n152 VDD.t26 0.228
R714 VDD.n152 VDD.t17 0.228
R715 VDD.n154 VDD.t8 0.228
R716 VDD.n154 VDD.t30 0.228
R717 VDD.n139 VDD.t143 0.228
R718 VDD.n139 VDD.t147 0.228
R719 VDD.n141 VDD.t137 0.228
R720 VDD.n141 VDD.t141 0.228
R721 VDD.n144 VDD.t135 0.228
R722 VDD.n144 VDD.t139 0.228
R723 VDD.n143 VDD.t129 0.228
R724 VDD.n143 VDD.t133 0.228
R725 VDD.n79 VDD.t93 0.228
R726 VDD.n79 VDD.t95 0.228
R727 VDD.n157 VDD.t44 0.228
R728 VDD.n157 VDD.t42 0.228
R729 VDD.n160 VDD.t3 0.228
R730 VDD.n160 VDD.t1 0.228
R731 VDD.n165 VDD.t21 0.228
R732 VDD.n165 VDD.t19 0.228
R733 VDD.n163 VDD.t36 0.228
R734 VDD.n163 VDD.t34 0.228
R735 VDD.n162 VDD.t161 0.228
R736 VDD.n162 VDD.t12 0.228
R737 VDD.n94 VDD.n93 0.213658
R738 VDD.n167 VDD.n159 0.189974
R739 VDD.n112 VDD.n82 0.189974
R740 VDD.n88 VDD.n86 0.189974
R741 VDD.n98 VDD.n96 0.189974
R742 VDD.n110 VDD.n108 0.189974
R743 VDD.n122 VDD.n120 0.189974
R744 VDD.n120 VDD.n118 0.189974
R745 VDD.n118 VDD.n116 0.189974
R746 VDD.n133 VDD.n131 0.189974
R747 VDD.n135 VDD.n133 0.189974
R748 VDD.n142 VDD.n140 0.189974
R749 VDD.n155 VDD.n153 0.189974
R750 VDD.n153 VDD.n151 0.189974
R751 VDD.n151 VDD.n149 0.189974
R752 VDD.n166 VDD.n164 0.189974
R753 VDD.n166 VDD.n161 0.189974
R754 VDD.n168 VDD.n78 0.146816
R755 VDD.n102 VDD.n101 0.118921
R756 VDD.n137 VDD.n126 0.0952368
R757 VDD.n111 VDD.n110 0.0952368
R758 VDD.n111 VDD.n105 0.0952368
R759 VDD.n146 VDD.n145 0.0952368
R760 VDD.n146 VDD.n142 0.0952368
R761 VDD.n89 VDD.n88 0.0948023
R762 VDD.n102 VDD.n98 0.0715526
R763 VDD VDD.n168 0.0205
R764 VSS.n134 VSS.n133 325
R765 VSS.n134 VSS.n85 325
R766 VSS.n67 VSS.n66 325
R767 VSS.n67 VSS.n16 325
R768 VSS.t18 VSS.t93 234
R769 VSS.n85 VSS.t75 234
R770 VSS.n66 VSS.t24 234
R771 VSS.t81 VSS.t118 234
R772 VSS.n126 VSS.t10 227.5
R773 VSS.n53 VSS.t120 227.5
R774 VSS.n133 VSS.t95 201.5
R775 VSS.t84 VSS.n16 201.5
R776 VSS.n8 VSS.t43 182
R777 VSS.n191 VSS.t124 152.136
R778 VSS.n126 VSS.n125 149.5
R779 VSS.n81 VSS.t25 149.5
R780 VSS.n74 VSS.t1 149.5
R781 VSS.n53 VSS.n23 149.5
R782 VSS.n182 VSS.t125 149.395
R783 VSS.t77 VSS.t86 130
R784 VSS.t27 VSS.t12 130
R785 VSS.n152 VSS.t45 117.001
R786 VSS.n8 VSS.t61 104.001
R787 VSS.n127 VSS.n89 87.5005
R788 VSS.n131 VSS.n89 87.5005
R789 VSS.n131 VSS.n84 87.5005
R790 VSS.n135 VSS.n84 87.5005
R791 VSS.n135 VSS.n82 87.5005
R792 VSS.n139 VSS.n82 87.5005
R793 VSS.n139 VSS.n7 87.5005
R794 VSS.n147 VSS.n7 87.5005
R795 VSS.n147 VSS.n4 87.5005
R796 VSS.n151 VSS.n4 87.5005
R797 VSS.n151 VSS.n3 87.5005
R798 VSS.n72 VSS.n3 87.5005
R799 VSS.n72 VSS.n13 87.5005
R800 VSS.n68 VSS.n13 87.5005
R801 VSS.n68 VSS.n15 87.5005
R802 VSS.n58 VSS.n15 87.5005
R803 VSS.n58 VSS.n20 87.5005
R804 VSS.n54 VSS.n20 87.5005
R805 VSS.n46 VSS.n25 87.5005
R806 VSS.n42 VSS.n40 87.5005
R807 VSS.n40 VSS.n39 87.5005
R808 VSS.n36 VSS.n35 87.5005
R809 VSS.n33 VSS.n30 87.5005
R810 VSS.n104 VSS.n92 87.5005
R811 VSS.n104 VSS.n88 87.5005
R812 VSS.n88 VSS.n87 87.5005
R813 VSS.n87 VSS.n86 87.5005
R814 VSS.n86 VSS.n80 87.5005
R815 VSS.n141 VSS.n80 87.5005
R816 VSS.n141 VSS.n10 87.5005
R817 VSS.n145 VSS.n10 87.5005
R818 VSS.n145 VSS.n9 87.5005
R819 VSS.n9 VSS.n2 87.5005
R820 VSS.n75 VSS.n2 87.5005
R821 VSS.n75 VSS.n12 87.5005
R822 VSS.n65 VSS.n12 87.5005
R823 VSS.n65 VSS.n17 87.5005
R824 VSS.n61 VSS.n17 87.5005
R825 VSS.n61 VSS.n60 87.5005
R826 VSS.n60 VSS.n19 87.5005
R827 VSS.n51 VSS.n19 87.5005
R828 VSS.n111 VSS.n110 87.5005
R829 VSS.n115 VSS.n114 87.5005
R830 VSS.n119 VSS.n118 87.5005
R831 VSS.n123 VSS.n98 87.5005
R832 VSS.t26 VSS.n1 84.5005
R833 VSS.n153 VSS.t0 84.5005
R834 VSS.n51 VSS.n48 68.2505
R835 VSS.n107 VSS.n92 68.2505
R836 VSS.n146 VSS.n1 65.0005
R837 VSS.n153 VSS.n152 65.0005
R838 VSS.n54 VSS.n22 50.7505
R839 VSS.n127 VSS.n91 50.7505
R840 VSS.n146 VSS.t49 39.0005
R841 VSS.n154 VSS.n1 29.6637
R842 VSS.n154 VSS.n153 28.4005
R843 VSS.n97 VSS.n91 26.2505
R844 VSS.t8 VSS.t10 26.0005
R845 VSS.t35 VSS.t8 26.0005
R846 VSS.t33 VSS.t35 26.0005
R847 VSS.t20 VSS.t18 26.0005
R848 VSS.t93 VSS.t91 26.0005
R849 VSS.t91 VSS.t41 26.0005
R850 VSS.t89 VSS.t39 26.0005
R851 VSS.t87 VSS.t89 26.0005
R852 VSS.t97 VSS.t87 26.0005
R853 VSS.t95 VSS.t97 26.0005
R854 VSS.t75 VSS.t22 26.0005
R855 VSS.t22 VSS.t17 26.0005
R856 VSS.t17 VSS.t99 26.0005
R857 VSS.t23 VSS.t72 26.0005
R858 VSS.t110 VSS.t77 26.0005
R859 VSS.t86 VSS.t108 26.0005
R860 VSS.t108 VSS.t14 26.0005
R861 VSS.t25 VSS.t26 26.0005
R862 VSS.t51 VSS.t49 26.0005
R863 VSS.t47 VSS.t51 26.0005
R864 VSS.t53 VSS.t47 26.0005
R865 VSS.t55 VSS.t53 26.0005
R866 VSS.t57 VSS.t55 26.0005
R867 VSS.t59 VSS.t57 26.0005
R868 VSS.t61 VSS.t59 26.0005
R869 VSS.t43 VSS.t45 26.0005
R870 VSS.t1 VSS.t0 26.0005
R871 VSS.t2 VSS.t83 26.0005
R872 VSS.t83 VSS.t27 26.0005
R873 VSS.t12 VSS.t37 26.0005
R874 VSS.t109 VSS.t3 26.0005
R875 VSS.t100 VSS.t102 26.0005
R876 VSS.t103 VSS.t100 26.0005
R877 VSS.t24 VSS.t103 26.0005
R878 VSS.t106 VSS.t84 26.0005
R879 VSS.t104 VSS.t106 26.0005
R880 VSS.t6 VSS.t104 26.0005
R881 VSS.t4 VSS.t6 26.0005
R882 VSS.t29 VSS.t31 26.0005
R883 VSS.t118 VSS.t29 26.0005
R884 VSS.t79 VSS.t81 26.0005
R885 VSS.t63 VSS.t65 26.0005
R886 VSS.t122 VSS.t63 26.0005
R887 VSS.t120 VSS.t122 26.0005
R888 VSS VSS.n0 21.0463
R889 VSS.n103 VSS.t33 19.5005
R890 VSS.t39 VSS.n132 19.5005
R891 VSS.t72 VSS.t15 19.5005
R892 VSS.t71 VSS.t73 19.5005
R893 VSS.t101 VSS.t110 19.5005
R894 VSS.t37 VSS.t76 19.5005
R895 VSS.t67 VSS.t28 19.5005
R896 VSS.t69 VSS.t109 19.5005
R897 VSS.n59 VSS.t4 19.5005
R898 VSS.t65 VSS.n52 19.5005
R899 VSS.n196 VSS.n195 19.4957
R900 VSS.n173 VSS.n172 19.3062
R901 VSS.n160 VSS.n159 18.4989
R902 VSS.n212 VSS.n211 16.9831
R903 VSS.n206 VSS.n205 16.9831
R904 VSS.n204 VSS.n197 16.9831
R905 VSS.n169 VSS.n168 16.9831
R906 VSS.n167 VSS.n160 16.9831
R907 VSS.n189 VSS.n188 15.8092
R908 VSS.n140 VSS.t99 13.0005
R909 VSS.n140 VSS.t23 13.0005
R910 VSS.t3 VSS.n73 13.0005
R911 VSS.n73 VSS.t102 13.0005
R912 VSS.n191 VSS.n190 9.98011
R913 VSS.n181 VSS.n174 8.57007
R914 VSS.n192 VSS.n191 8.57007
R915 VSS.n103 VSS.t20 6.5005
R916 VSS.n132 VSS.t41 6.5005
R917 VSS.t15 VSS.t71 6.5005
R918 VSS.t73 VSS.t101 6.5005
R919 VSS.t14 VSS.n81 6.5005
R920 VSS.n74 VSS.t2 6.5005
R921 VSS.t76 VSS.t67 6.5005
R922 VSS.t28 VSS.t69 6.5005
R923 VSS.n59 VSS.t31 6.5005
R924 VSS.n52 VSS.t79 6.5005
R925 VSS.n197 VSS.n196 6.20576
R926 VSS.n210 VSS.n208 5.57485
R927 VSS.n201 VSS.n199 5.57485
R928 VSS.n195 VSS.n193 5.57485
R929 VSS.n179 VSS.n177 5.57485
R930 VSS.n185 VSS.n183 5.57485
R931 VSS.n164 VSS.n162 5.57485
R932 VSS.n158 VSS.n156 5.57485
R933 VSS.n172 VSS.n170 5.57485
R934 VSS.n211 VSS.n207 5.48011
R935 VSS.n180 VSS.n176 5.48011
R936 VSS.n159 VSS.n155 5.48011
R937 VSS.n210 VSS.n209 5.38537
R938 VSS.n205 VSS.n198 5.38537
R939 VSS.n203 VSS.n202 5.38537
R940 VSS.n201 VSS.n200 5.38537
R941 VSS.n195 VSS.n194 5.38537
R942 VSS.n188 VSS.n175 5.38537
R943 VSS.n179 VSS.n178 5.38537
R944 VSS.n187 VSS.n186 5.38537
R945 VSS.n185 VSS.n184 5.38537
R946 VSS.n168 VSS.n161 5.38537
R947 VSS.n166 VSS.n165 5.38537
R948 VSS.n164 VSS.n163 5.38537
R949 VSS.n158 VSS.n157 5.38537
R950 VSS.n172 VSS.n171 5.38537
R951 VSS.n53 VSS.n51 5.2005
R952 VSS.n51 VSS.n50 5.2005
R953 VSS.n52 VSS.n19 5.2005
R954 VSS.n49 VSS.n19 5.2005
R955 VSS.n60 VSS.n59 5.2005
R956 VSS.n60 VSS.n18 5.2005
R957 VSS.n61 VSS.n16 5.2005
R958 VSS.n62 VSS.n61 5.2005
R959 VSS.n67 VSS.n17 5.2005
R960 VSS.n63 VSS.n17 5.2005
R961 VSS.n66 VSS.n65 5.2005
R962 VSS.n65 VSS.n64 5.2005
R963 VSS.n73 VSS.n12 5.2005
R964 VSS.n12 VSS.n11 5.2005
R965 VSS.n75 VSS.n74 5.2005
R966 VSS.n76 VSS.n75 5.2005
R967 VSS.n152 VSS.n2 5.2005
R968 VSS.n77 VSS.n2 5.2005
R969 VSS.n9 VSS.n8 5.2005
R970 VSS.n78 VSS.n9 5.2005
R971 VSS.n146 VSS.n145 5.2005
R972 VSS.n145 VSS.n144 5.2005
R973 VSS.n81 VSS.n10 5.2005
R974 VSS.n143 VSS.n10 5.2005
R975 VSS.n141 VSS.n140 5.2005
R976 VSS.n142 VSS.n141 5.2005
R977 VSS.n85 VSS.n80 5.2005
R978 VSS.n80 VSS.n79 5.2005
R979 VSS.n134 VSS.n86 5.2005
R980 VSS.n100 VSS.n86 5.2005
R981 VSS.n133 VSS.n87 5.2005
R982 VSS.n101 VSS.n87 5.2005
R983 VSS.n132 VSS.n88 5.2005
R984 VSS.n102 VSS.n88 5.2005
R985 VSS.n104 VSS.n103 5.2005
R986 VSS.n105 VSS.n104 5.2005
R987 VSS.n126 VSS.n92 5.2005
R988 VSS.n106 VSS.n92 5.2005
R989 VSS.n125 VSS.n91 5.2005
R990 VSS.n91 VSS.n90 5.2005
R991 VSS.n99 VSS.n97 5.2005
R992 VSS.n123 VSS.n122 5.2005
R993 VSS.n121 VSS.n98 5.2005
R994 VSS.n120 VSS.n119 5.2005
R995 VSS.n118 VSS.n117 5.2005
R996 VSS.n116 VSS.n115 5.2005
R997 VSS.n114 VSS.n113 5.2005
R998 VSS.n112 VSS.n111 5.2005
R999 VSS.n110 VSS.n109 5.2005
R1000 VSS.n108 VSS.n107 5.2005
R1001 VSS.n48 VSS.n24 5.2005
R1002 VSS.n46 VSS.n45 5.2005
R1003 VSS.n44 VSS.n25 5.2005
R1004 VSS.n43 VSS.n42 5.2005
R1005 VSS.n40 VSS.n23 5.2005
R1006 VSS.n40 VSS.n26 5.2005
R1007 VSS.n39 VSS.n38 5.2005
R1008 VSS.n37 VSS.n36 5.2005
R1009 VSS.n35 VSS.n28 5.2005
R1010 VSS.n33 VSS.n32 5.2005
R1011 VSS.n31 VSS.n30 5.2005
R1012 VSS.n22 VSS.n21 5.2005
R1013 VSS.n54 VSS.n53 5.2005
R1014 VSS.n55 VSS.n54 5.2005
R1015 VSS.n52 VSS.n20 5.2005
R1016 VSS.n56 VSS.n20 5.2005
R1017 VSS.n59 VSS.n58 5.2005
R1018 VSS.n58 VSS.n57 5.2005
R1019 VSS.n16 VSS.n15 5.2005
R1020 VSS.n15 VSS.n14 5.2005
R1021 VSS.n68 VSS.n67 5.2005
R1022 VSS.n69 VSS.n68 5.2005
R1023 VSS.n66 VSS.n13 5.2005
R1024 VSS.n70 VSS.n13 5.2005
R1025 VSS.n73 VSS.n72 5.2005
R1026 VSS.n72 VSS.n71 5.2005
R1027 VSS.n74 VSS.n3 5.2005
R1028 VSS.n5 VSS.n3 5.2005
R1029 VSS.n152 VSS.n151 5.2005
R1030 VSS.n151 VSS.n150 5.2005
R1031 VSS.n8 VSS.n4 5.2005
R1032 VSS.n149 VSS.n4 5.2005
R1033 VSS.n147 VSS.n146 5.2005
R1034 VSS.n148 VSS.n147 5.2005
R1035 VSS.n81 VSS.n7 5.2005
R1036 VSS.n7 VSS.n6 5.2005
R1037 VSS.n140 VSS.n139 5.2005
R1038 VSS.n139 VSS.n138 5.2005
R1039 VSS.n85 VSS.n82 5.2005
R1040 VSS.n137 VSS.n82 5.2005
R1041 VSS.n135 VSS.n134 5.2005
R1042 VSS.n136 VSS.n135 5.2005
R1043 VSS.n133 VSS.n84 5.2005
R1044 VSS.n84 VSS.n83 5.2005
R1045 VSS.n132 VSS.n131 5.2005
R1046 VSS.n131 VSS.n130 5.2005
R1047 VSS.n103 VSS.n89 5.2005
R1048 VSS.n129 VSS.n89 5.2005
R1049 VSS.n127 VSS.n126 5.2005
R1050 VSS.n128 VSS.n127 5.2005
R1051 VSS.n213 VSS.n212 4.87945
R1052 VSS.n124 VSS.n97 4.6486
R1053 VSS.n98 VSS.n96 4.6486
R1054 VSS.n118 VSS.n95 4.6486
R1055 VSS.n114 VSS.n94 4.6486
R1056 VSS.n110 VSS.n93 4.6486
R1057 VSS.n48 VSS.n47 4.6486
R1058 VSS.n41 VSS.n25 4.6486
R1059 VSS.n36 VSS.n27 4.6486
R1060 VSS.n34 VSS.n33 4.6486
R1061 VSS.n47 VSS.n46 4.6486
R1062 VSS.n42 VSS.n41 4.6486
R1063 VSS.n39 VSS.n27 4.6486
R1064 VSS.n35 VSS.n34 4.6486
R1065 VSS.n107 VSS.n93 4.6486
R1066 VSS.n111 VSS.n94 4.6486
R1067 VSS.n115 VSS.n95 4.6486
R1068 VSS.n119 VSS.n96 4.6486
R1069 VSS.n124 VSS.n123 4.6486
R1070 VSS.n187 VSS.n182 4.5005
R1071 VSS.n181 VSS.n180 4.5005
R1072 VSS.n213 VSS.n154 4.49787
R1073 VSS.n173 VSS.n169 3.83734
R1074 VSS.n30 VSS.n29 3.72542
R1075 VSS.n29 VSS.n22 3.72542
R1076 VSS.n174 VSS.n173 3.43471
R1077 VSS.n182 VSS.n181 2.73963
R1078 VSS.n196 VSS.n192 1.3505
R1079 VSS.n192 VSS.n189 1.23208
R1080 VSS.n212 VSS.n206 1.23208
R1081 VSS.n129 VSS.n128 1.1255
R1082 VSS.n130 VSS.n129 1.1255
R1083 VSS.n130 VSS.n83 1.1255
R1084 VSS.n136 VSS.n83 1.1255
R1085 VSS.n137 VSS.n136 1.1255
R1086 VSS.n138 VSS.n137 1.1255
R1087 VSS.n138 VSS.n6 1.1255
R1088 VSS.n148 VSS.n6 1.1255
R1089 VSS.n149 VSS.n148 1.1255
R1090 VSS.n150 VSS.n149 1.1255
R1091 VSS.n150 VSS.n5 1.1255
R1092 VSS.n71 VSS.n5 1.1255
R1093 VSS.n71 VSS.n70 1.1255
R1094 VSS.n70 VSS.n69 1.1255
R1095 VSS.n69 VSS.n14 1.1255
R1096 VSS.n57 VSS.n14 1.1255
R1097 VSS.n57 VSS.n56 1.1255
R1098 VSS.n56 VSS.n55 1.1255
R1099 VSS.n45 VSS.n24 1.1255
R1100 VSS.n45 VSS.n44 1.1255
R1101 VSS.n44 VSS.n43 1.1255
R1102 VSS.n43 VSS.n26 1.1255
R1103 VSS.n38 VSS.n26 1.1255
R1104 VSS.n38 VSS.n37 1.1255
R1105 VSS.n37 VSS.n28 1.1255
R1106 VSS.n32 VSS.n28 1.1255
R1107 VSS.n32 VSS.n31 1.1255
R1108 VSS.n106 VSS.n105 1.1255
R1109 VSS.n105 VSS.n102 1.1255
R1110 VSS.n102 VSS.n101 1.1255
R1111 VSS.n101 VSS.n100 1.1255
R1112 VSS.n100 VSS.n79 1.1255
R1113 VSS.n142 VSS.n79 1.1255
R1114 VSS.n143 VSS.n142 1.1255
R1115 VSS.n144 VSS.n143 1.1255
R1116 VSS.n144 VSS.n78 1.1255
R1117 VSS.n78 VSS.n77 1.1255
R1118 VSS.n77 VSS.n76 1.1255
R1119 VSS.n76 VSS.n11 1.1255
R1120 VSS.n64 VSS.n11 1.1255
R1121 VSS.n64 VSS.n63 1.1255
R1122 VSS.n63 VSS.n62 1.1255
R1123 VSS.n62 VSS.n18 1.1255
R1124 VSS.n49 VSS.n18 1.1255
R1125 VSS.n50 VSS.n49 1.1255
R1126 VSS.n109 VSS.n108 1.1255
R1127 VSS.n112 VSS.n109 1.1255
R1128 VSS.n113 VSS.n112 1.1255
R1129 VSS.n116 VSS.n113 1.1255
R1130 VSS.n117 VSS.n116 1.1255
R1131 VSS.n120 VSS.n117 1.1255
R1132 VSS.n121 VSS.n120 1.1255
R1133 VSS.n122 VSS.n121 1.1255
R1134 VSS.n122 VSS.n99 1.1255
R1135 VSS.n108 VSS.n106 0.878
R1136 VSS.n29 VSS.n23 0.73879
R1137 VSS.n55 VSS.n21 0.653
R1138 VSS.n128 VSS.n90 0.653
R1139 VSS.n50 VSS.n0 0.518
R1140 VSS.n24 VSS.n0 0.3605
R1141 VSS.n31 VSS.n21 0.338
R1142 VSS.n99 VSS.n90 0.338
R1143 VSS.n125 VSS.n124 0.2772
R1144 VSS.n125 VSS.n96 0.2772
R1145 VSS.n125 VSS.n95 0.2772
R1146 VSS.n125 VSS.n94 0.2772
R1147 VSS.n125 VSS.n93 0.2772
R1148 VSS.n47 VSS.n23 0.2772
R1149 VSS.n41 VSS.n23 0.2772
R1150 VSS.n27 VSS.n23 0.2772
R1151 VSS.n34 VSS.n23 0.2772
R1152 VSS.n207 VSS.t123 0.20525
R1153 VSS.n207 VSS.t121 0.20525
R1154 VSS.n209 VSS.t66 0.20525
R1155 VSS.n209 VSS.t64 0.20525
R1156 VSS.n208 VSS.t82 0.20525
R1157 VSS.n208 VSS.t80 0.20525
R1158 VSS.n198 VSS.t30 0.20525
R1159 VSS.n198 VSS.t119 0.20525
R1160 VSS.n202 VSS.t5 0.20525
R1161 VSS.n202 VSS.t32 0.20525
R1162 VSS.n200 VSS.t105 0.20525
R1163 VSS.n200 VSS.t7 0.20525
R1164 VSS.n199 VSS.t85 0.20525
R1165 VSS.n199 VSS.t107 0.20525
R1166 VSS.n193 VSS.t68 0.20525
R1167 VSS.n193 VSS.t70 0.20525
R1168 VSS.n194 VSS.t13 0.20525
R1169 VSS.n194 VSS.t38 0.20525
R1170 VSS.n175 VSS.t60 0.20525
R1171 VSS.n175 VSS.t62 0.20525
R1172 VSS.n176 VSS.t116 0.20525
R1173 VSS.n176 VSS.t117 0.20525
R1174 VSS.n178 VSS.t114 0.20525
R1175 VSS.n178 VSS.t115 0.20525
R1176 VSS.n177 VSS.t112 0.20525
R1177 VSS.n177 VSS.t113 0.20525
R1178 VSS.n186 VSS.t56 0.20525
R1179 VSS.n186 VSS.t58 0.20525
R1180 VSS.n184 VSS.t48 0.20525
R1181 VSS.n184 VSS.t54 0.20525
R1182 VSS.n183 VSS.t50 0.20525
R1183 VSS.n183 VSS.t52 0.20525
R1184 VSS.n190 VSS.t44 0.20525
R1185 VSS.n190 VSS.t46 0.20525
R1186 VSS.n161 VSS.t98 0.20525
R1187 VSS.n161 VSS.t96 0.20525
R1188 VSS.n165 VSS.t90 0.20525
R1189 VSS.n165 VSS.t88 0.20525
R1190 VSS.n163 VSS.t42 0.20525
R1191 VSS.n163 VSS.t40 0.20525
R1192 VSS.n162 VSS.t94 0.20525
R1193 VSS.n162 VSS.t92 0.20525
R1194 VSS.n155 VSS.t21 0.20525
R1195 VSS.n155 VSS.t19 0.20525
R1196 VSS.n157 VSS.t36 0.20525
R1197 VSS.n157 VSS.t34 0.20525
R1198 VSS.n156 VSS.t11 0.20525
R1199 VSS.n156 VSS.t9 0.20525
R1200 VSS.n170 VSS.t111 0.20525
R1201 VSS.n170 VSS.t78 0.20525
R1202 VSS.n171 VSS.t16 0.20525
R1203 VSS.n171 VSS.t74 0.20525
R1204 VSS.n189 VSS.n174 0.189974
R1205 VSS.n203 VSS.n201 0.189974
R1206 VSS.n187 VSS.n185 0.189974
R1207 VSS.n188 VSS.n187 0.189974
R1208 VSS.n166 VSS.n164 0.189974
R1209 VSS.n169 VSS.n160 0.0952368
R1210 VSS.n206 VSS.n197 0.0952368
R1211 VSS.n211 VSS.n210 0.0952368
R1212 VSS.n204 VSS.n203 0.0952368
R1213 VSS.n205 VSS.n204 0.0952368
R1214 VSS.n180 VSS.n179 0.0952368
R1215 VSS.n167 VSS.n166 0.0952368
R1216 VSS.n168 VSS.n167 0.0952368
R1217 VSS.n159 VSS.n158 0.0952368
R1218 VSS VSS.n213 0.0205
R1219 NTAIL.n2 NTAIL.n0 20.6105
R1220 NTAIL.n10 NTAIL.n9 18.5365
R1221 NTAIL.n8 NTAIL.n7 10.6141
R1222 NTAIL.n2 NTAIL.n1 10.6141
R1223 NTAIL.n1 NTAIL.t5 5.7796
R1224 NTAIL.n4 NTAIL.t11 5.7796
R1225 NTAIL.n7 NTAIL.t6 5.68486
R1226 NTAIL.n1 NTAIL.t4 5.59012
R1227 NTAIL.n4 NTAIL.n3 5.38537
R1228 NTAIL.n6 NTAIL.n5 5.38537
R1229 NTAIL.n8 NTAIL.n2 2.50485
R1230 NTAIL.n10 NTAIL.n8 1.2918
R1231 NTAIL.n3 NTAIL.t9 0.20525
R1232 NTAIL.n3 NTAIL.t10 0.20525
R1233 NTAIL.n0 NTAIL.t0 0.20525
R1234 NTAIL.n0 NTAIL.t1 0.20525
R1235 NTAIL.n9 NTAIL.t3 0.20525
R1236 NTAIL.n9 NTAIL.t2 0.20525
R1237 NTAIL.n5 NTAIL.t7 0.20525
R1238 NTAIL.n5 NTAIL.t8 0.20525
R1239 NTAIL.n6 NTAIL.n4 0.189974
R1240 NTAIL.n7 NTAIL.n6 0.0952368
R1241 NTAIL NTAIL.n10 0.0396304
R1242 BN.n16 BN.t10 113.632
R1243 BN.n2 BN.t23 113.632
R1244 BN.n6 BN.t16 113.632
R1245 BN.n21 BN.t15 109.174
R1246 BN.n20 BN.t14 109.174
R1247 BN.n19 BN.t13 109.174
R1248 BN.n14 BN.t12 109.174
R1249 BN.n15 BN.t11 109.174
R1250 BN.n9 BN.t19 109.174
R1251 BN.n10 BN.t20 109.174
R1252 BN.n3 BN.t22 109.174
R1253 BN.n4 BN.t21 109.174
R1254 BN.n8 BN.t18 109.174
R1255 BN.n5 BN.t17 109.174
R1256 BN.n22 BN.n21 18.4942
R1257 BN.n20 BN.n13 18.4942
R1258 BN.n19 BN.n18 18.4942
R1259 BN.n17 BN.n14 18.4942
R1260 BN.n9 BN.n0 18.4942
R1261 BN.n11 BN.n10 18.4942
R1262 BN.n4 BN.n1 18.4942
R1263 BN.n8 BN.n7 18.4942
R1264 BN.n23 BN.n22 15.5414
R1265 BN.n21 BN.n20 11.6805
R1266 BN.n20 BN.n19 11.6805
R1267 BN.n19 BN.n14 11.6805
R1268 BN.n15 BN.n14 11.6805
R1269 BN.n9 BN.n8 11.6805
R1270 BN.n10 BN.n9 11.6805
R1271 BN.n4 BN.n3 11.6805
R1272 BN.n10 BN.n4 11.6805
R1273 BN.n8 BN.n5 11.6805
R1274 BN.n23 BN.n12 9.87478
R1275 BN.n32 BN.n31 8.36407
R1276 BN.n32 BN.n24 7.91407
R1277 BN.n17 BN.n16 7.17687
R1278 BN.n7 BN.n6 7.17687
R1279 BN.n2 BN.n1 7.17687
R1280 BN.n33 BN.n23 6.41789
R1281 BN.n26 BN.t9 5.7796
R1282 BN.n30 BN.t5 5.7796
R1283 BN.n24 BN.t6 5.73764
R1284 BN.n24 BN.t4 5.54817
R1285 BN.n28 BN.n27 5.38537
R1286 BN.n26 BN.n25 5.38537
R1287 BN.n30 BN.n29 5.38537
R1288 BN.n33 BN.n32 4.5005
R1289 BN.n16 BN.n15 4.42851
R1290 BN.n3 BN.n2 4.42851
R1291 BN.n6 BN.n5 4.42851
R1292 BN.n27 BN.t1 0.20525
R1293 BN.n27 BN.t0 0.20525
R1294 BN.n25 BN.t3 0.20525
R1295 BN.n25 BN.t2 0.20525
R1296 BN.n29 BN.t8 0.20525
R1297 BN.n29 BN.t7 0.20525
R1298 BN.n28 BN.n26 0.189974
R1299 BN.n22 BN.n13 0.1205
R1300 BN.n18 BN.n13 0.1205
R1301 BN.n18 BN.n17 0.1205
R1302 BN.n7 BN.n0 0.1205
R1303 BN.n11 BN.n1 0.1205
R1304 BN.n31 BN.n30 0.0952368
R1305 BN.n31 BN.n28 0.0952368
R1306 BN.n12 BN.n0 0.0485
R1307 BN.n12 BN.n11 0.0485
R1308 BN BN.n33 0.0396304
R1309 SXN.n3 SXN.t19 113.632
R1310 SXN.n7 SXN.t12 113.632
R1311 SXN.n0 SXN.t20 113.618
R1312 SXN.n0 SXN.t21 113.618
R1313 SXN.n10 SXN.t15 109.174
R1314 SXN.n11 SXN.t16 109.174
R1315 SXN.n4 SXN.t18 109.174
R1316 SXN.n5 SXN.t17 109.174
R1317 SXN.n9 SXN.t14 109.174
R1318 SXN.n6 SXN.t13 109.174
R1319 SXN.n14 SXN.n0 21.4356
R1320 SXN.n10 SXN.n1 18.4942
R1321 SXN.n12 SXN.n11 18.4942
R1322 SXN.n5 SXN.n2 18.4942
R1323 SXN.n9 SXN.n8 18.4942
R1324 SXN.n26 SXN.n25 17.1983
R1325 SXN.n18 SXN.n17 12.7558
R1326 SXN.n10 SXN.n9 11.6805
R1327 SXN.n11 SXN.n10 11.6805
R1328 SXN.n5 SXN.n4 11.6805
R1329 SXN.n11 SXN.n5 11.6805
R1330 SXN.n9 SXN.n6 11.6805
R1331 SXN.n18 SXN.n14 11.3092
R1332 SXN.n14 SXN.n13 10.9034
R1333 SXN.n8 SXN.n7 7.17687
R1334 SXN.n3 SXN.n2 7.17687
R1335 SXN.n16 SXN.t1 5.7796
R1336 SXN.n20 SXN.t6 5.73764
R1337 SXN.n17 SXN.t5 5.59012
R1338 SXN.n25 SXN.t9 5.54817
R1339 SXN.n16 SXN.n15 5.38537
R1340 SXN.n24 SXN.n23 5.32067
R1341 SXN.n22 SXN.n21 5.32067
R1342 SXN.n20 SXN.n19 5.32067
R1343 SXN.n4 SXN.n3 4.42851
R1344 SXN.n7 SXN.n6 4.42851
R1345 SXN.n26 SXN.n18 0.313543
R1346 SXN.n23 SXN.t2 0.228
R1347 SXN.n23 SXN.t0 0.228
R1348 SXN.n21 SXN.t11 0.228
R1349 SXN.n21 SXN.t7 0.228
R1350 SXN.n19 SXN.t8 0.228
R1351 SXN.n19 SXN.t10 0.228
R1352 SXN.n15 SXN.t3 0.20525
R1353 SXN.n15 SXN.t4 0.20525
R1354 SXN.n22 SXN.n20 0.189974
R1355 SXN.n24 SXN.n22 0.189974
R1356 SXN.n25 SXN.n24 0.189974
R1357 SXN.n17 SXN.n16 0.189974
R1358 SXN.n8 SXN.n1 0.1205
R1359 SXN.n12 SXN.n2 0.1205
R1360 SXN.n13 SXN.n1 0.0485
R1361 SXN.n13 SXN.n12 0.0485
R1362 SXN SXN.n26 0.0396304
R1363 SXP.n14 SXP.t19 113.632
R1364 SXP.n18 SXP.t12 113.632
R1365 SXP.n11 SXP.t20 113.618
R1366 SXP.n11 SXP.t21 113.618
R1367 SXP.n21 SXP.t15 109.174
R1368 SXP.n22 SXP.t16 109.174
R1369 SXP.n15 SXP.t18 109.174
R1370 SXP.n16 SXP.t17 109.174
R1371 SXP.n20 SXP.t14 109.174
R1372 SXP.n17 SXP.t13 109.174
R1373 SXP.n25 SXP.n11 21.8856
R1374 SXP.n21 SXP.n12 18.4942
R1375 SXP.n23 SXP.n22 18.4942
R1376 SXP.n16 SXP.n13 18.4942
R1377 SXP.n20 SXP.n19 18.4942
R1378 SXP.n26 SXP.n10 15.1644
R1379 SXP.n21 SXP.n20 11.6805
R1380 SXP.n22 SXP.n21 11.6805
R1381 SXP.n16 SXP.n15 11.6805
R1382 SXP.n22 SXP.n16 11.6805
R1383 SXP.n20 SXP.n17 11.6805
R1384 SXP.n25 SXP.n24 10.4534
R1385 SXP.n10 SXP.n6 9.54828
R1386 SXP.n19 SXP.n18 7.17687
R1387 SXP.n14 SXP.n13 7.17687
R1388 SXP.n8 SXP.t10 5.7796
R1389 SXP.n1 SXP.t5 5.73764
R1390 SXP.n9 SXP.t3 5.59012
R1391 SXP.n6 SXP.t0 5.54817
R1392 SXP.n8 SXP.n7 5.38537
R1393 SXP.n1 SXP.n0 5.32067
R1394 SXP.n3 SXP.n2 5.32067
R1395 SXP.n5 SXP.n4 5.32067
R1396 SXP.n10 SXP.n9 4.97418
R1397 SXP.n26 SXP.n25 4.5005
R1398 SXP.n15 SXP.n14 4.42851
R1399 SXP.n18 SXP.n17 4.42851
R1400 SXP.n0 SXP.t1 0.228
R1401 SXP.n0 SXP.t7 0.228
R1402 SXP.n2 SXP.t2 0.228
R1403 SXP.n2 SXP.t8 0.228
R1404 SXP.n4 SXP.t6 0.228
R1405 SXP.n4 SXP.t4 0.228
R1406 SXP.n7 SXP.t9 0.20525
R1407 SXP.n7 SXP.t11 0.20525
R1408 SXP.n6 SXP.n5 0.189974
R1409 SXP.n5 SXP.n3 0.189974
R1410 SXP.n3 SXP.n1 0.189974
R1411 SXP.n9 SXP.n8 0.189974
R1412 SXP.n19 SXP.n12 0.1205
R1413 SXP.n23 SXP.n13 0.1205
R1414 SXP.n24 SXP.n12 0.0485
R1415 SXP.n24 SXP.n23 0.0485
R1416 SXP SXP.n26 0.0396304
R1417 BP.n25 BP.t15 113.632
R1418 BP.n11 BP.t23 113.632
R1419 BP.n15 BP.t16 113.632
R1420 BP.n26 BP.t14 109.174
R1421 BP.n27 BP.t13 109.174
R1422 BP.n28 BP.t12 109.174
R1423 BP.n29 BP.t11 109.174
R1424 BP.n30 BP.t10 109.174
R1425 BP.n18 BP.t19 109.174
R1426 BP.n19 BP.t20 109.174
R1427 BP.n12 BP.t22 109.174
R1428 BP.n13 BP.t21 109.174
R1429 BP.n17 BP.t18 109.174
R1430 BP.n14 BP.t17 109.174
R1431 BP.n27 BP.n24 18.4942
R1432 BP.n28 BP.n23 18.4942
R1433 BP.n29 BP.n22 18.4942
R1434 BP.n31 BP.n30 18.4942
R1435 BP.n18 BP.n9 18.4942
R1436 BP.n20 BP.n19 18.4942
R1437 BP.n13 BP.n10 18.4942
R1438 BP.n17 BP.n16 18.4942
R1439 BP.n32 BP.n31 15.0914
R1440 BP.n27 BP.n26 11.6805
R1441 BP.n28 BP.n27 11.6805
R1442 BP.n29 BP.n28 11.6805
R1443 BP.n30 BP.n29 11.6805
R1444 BP.n18 BP.n17 11.6805
R1445 BP.n19 BP.n18 11.6805
R1446 BP.n13 BP.n12 11.6805
R1447 BP.n19 BP.n13 11.6805
R1448 BP.n17 BP.n14 11.6805
R1449 BP.n32 BP.n21 10.3248
R1450 BP.n8 BP.n0 8.36407
R1451 BP.n8 BP.n7 7.91407
R1452 BP.n25 BP.n24 7.17687
R1453 BP.n16 BP.n15 7.17687
R1454 BP.n11 BP.n10 7.17687
R1455 BP.n33 BP.n8 6.10485
R1456 BP.n2 BP.t7 5.7796
R1457 BP.n6 BP.t0 5.7796
R1458 BP.n0 BP.t9 5.73764
R1459 BP.n0 BP.t8 5.54817
R1460 BP.n2 BP.n1 5.38537
R1461 BP.n4 BP.n3 5.38537
R1462 BP.n6 BP.n5 5.38537
R1463 BP.n33 BP.n32 4.5005
R1464 BP.n26 BP.n25 4.42851
R1465 BP.n12 BP.n11 4.42851
R1466 BP.n15 BP.n14 4.42851
R1467 BP.n1 BP.t5 0.20525
R1468 BP.n1 BP.t6 0.20525
R1469 BP.n3 BP.t3 0.20525
R1470 BP.n3 BP.t4 0.20525
R1471 BP.n5 BP.t1 0.20525
R1472 BP.n5 BP.t2 0.20525
R1473 BP.n4 BP.n2 0.189974
R1474 BP.n24 BP.n23 0.1205
R1475 BP.n23 BP.n22 0.1205
R1476 BP.n31 BP.n22 0.1205
R1477 BP.n16 BP.n9 0.1205
R1478 BP.n20 BP.n10 0.1205
R1479 BP.n7 BP.n6 0.0952368
R1480 BP.n7 BP.n4 0.0952368
R1481 BP.n21 BP.n9 0.0485
R1482 BP.n21 BP.n20 0.0485
R1483 BP BP.n33 0.0396304
R1484 NREGEN.n7 NREGEN.n0 18.0069
R1485 NREGEN.n29 NREGEN.n22 18.0069
R1486 NREGEN.n10 NREGEN.n9 10.6614
R1487 NREGEN.n21 NREGEN.n20 10.6614
R1488 NREGEN.n18 NREGEN.n17 9.32836
R1489 NREGEN.n7 NREGEN.n6 6.11407
R1490 NREGEN.n29 NREGEN.n28 6.11407
R1491 NREGEN.n10 NREGEN.n7 6.10485
R1492 NREGEN.n12 NREGEN.t16 5.7796
R1493 NREGEN.n16 NREGEN.t9 5.7796
R1494 NREGEN.n18 NREGEN.n10 5.75267
R1495 NREGEN.n0 NREGEN.t19 5.73764
R1496 NREGEN.n22 NREGEN.t17 5.73764
R1497 NREGEN.n9 NREGEN.t7 5.59012
R1498 NREGEN.n20 NREGEN.t2 5.59012
R1499 NREGEN.n9 NREGEN.n8 5.57485
R1500 NREGEN.n20 NREGEN.n19 5.57485
R1501 NREGEN.n6 NREGEN.n1 5.57485
R1502 NREGEN.n5 NREGEN.n3 5.57485
R1503 NREGEN.n28 NREGEN.n23 5.57485
R1504 NREGEN.n27 NREGEN.n25 5.57485
R1505 NREGEN.n0 NREGEN.t20 5.54817
R1506 NREGEN.n22 NREGEN.t18 5.54817
R1507 NREGEN.n6 NREGEN.n2 5.38537
R1508 NREGEN.n5 NREGEN.n4 5.38537
R1509 NREGEN.n28 NREGEN.n24 5.38537
R1510 NREGEN.n27 NREGEN.n26 5.38537
R1511 NREGEN.n12 NREGEN.n11 5.38537
R1512 NREGEN.n14 NREGEN.n13 5.38537
R1513 NREGEN.n16 NREGEN.n15 5.38537
R1514 NREGEN.n30 NREGEN.n29 4.5005
R1515 NREGEN.n21 NREGEN.n18 2.46572
R1516 NREGEN.n30 NREGEN.n21 1.91789
R1517 NREGEN.n8 NREGEN.t0 0.20525
R1518 NREGEN.n8 NREGEN.t25 0.20525
R1519 NREGEN.n19 NREGEN.t26 0.20525
R1520 NREGEN.n19 NREGEN.t32 0.20525
R1521 NREGEN.n1 NREGEN.t31 0.20525
R1522 NREGEN.n1 NREGEN.t6 0.20525
R1523 NREGEN.n2 NREGEN.t30 0.20525
R1524 NREGEN.n2 NREGEN.t28 0.20525
R1525 NREGEN.n4 NREGEN.t33 0.20525
R1526 NREGEN.n4 NREGEN.t1 0.20525
R1527 NREGEN.n3 NREGEN.t24 0.20525
R1528 NREGEN.n3 NREGEN.t8 0.20525
R1529 NREGEN.n23 NREGEN.t21 0.20525
R1530 NREGEN.n23 NREGEN.t29 0.20525
R1531 NREGEN.n24 NREGEN.t5 0.20525
R1532 NREGEN.n24 NREGEN.t22 0.20525
R1533 NREGEN.n26 NREGEN.t3 0.20525
R1534 NREGEN.n26 NREGEN.t27 0.20525
R1535 NREGEN.n25 NREGEN.t23 0.20525
R1536 NREGEN.n25 NREGEN.t4 0.20525
R1537 NREGEN.n11 NREGEN.t14 0.20525
R1538 NREGEN.n11 NREGEN.t15 0.20525
R1539 NREGEN.n13 NREGEN.t12 0.20525
R1540 NREGEN.n13 NREGEN.t13 0.20525
R1541 NREGEN.n15 NREGEN.t10 0.20525
R1542 NREGEN.n15 NREGEN.t11 0.20525
R1543 NREGEN.n14 NREGEN.n12 0.189974
R1544 NREGEN.n6 NREGEN.n5 0.189974
R1545 NREGEN.n28 NREGEN.n27 0.189974
R1546 NREGEN.n17 NREGEN.n16 0.0952368
R1547 NREGEN.n17 NREGEN.n14 0.0952368
R1548 NREGEN NREGEN.n30 0.0396304
R1549 XN.n70 XN.t57 127.788
R1550 XN.t50 XN.n60 127.788
R1551 XN.n67 XN.t53 127.668
R1552 XN.n70 XN.t56 127.668
R1553 XN.t55 XN.n71 127.668
R1554 XN.t54 XN.n68 127.668
R1555 XN.t51 XN.n60 127.668
R1556 XN.n66 XN.t52 127.668
R1557 XN.n22 XN.t41 113.632
R1558 XN.n5 XN.t49 113.632
R1559 XN.n76 XN.t37 113.632
R1560 XN.t57 XN.n57 113.632
R1561 XN.n63 XN.t50 113.632
R1562 XN.n23 XN.t40 109.174
R1563 XN.n24 XN.t39 109.174
R1564 XN.n25 XN.t38 109.174
R1565 XN.n0 XN.t42 109.174
R1566 XN.n11 XN.t43 109.174
R1567 XN.n10 XN.t44 109.174
R1568 XN.n6 XN.t48 109.174
R1569 XN.n7 XN.t47 109.174
R1570 XN.n8 XN.t46 109.174
R1571 XN.n9 XN.t45 109.174
R1572 XN.n77 XN.t36 109.174
R1573 XN.n78 XN.t35 109.174
R1574 XN.t53 XN.n59 109.174
R1575 XN.t56 XN.n58 109.174
R1576 XN.n72 XN.t55 109.174
R1577 XN.n69 XN.t54 109.174
R1578 XN.n64 XN.t51 109.174
R1579 XN.t52 XN.n65 109.174
R1580 XN.n46 XN.n45 21.0284
R1581 XN.n54 XN.n53 18.9712
R1582 XN.n13 XN.n0 18.5723
R1583 XN.n24 XN.n21 18.4942
R1584 XN.n26 XN.n25 18.4942
R1585 XN.n12 XN.n11 18.4942
R1586 XN.n10 XN.n1 18.4942
R1587 XN.n7 XN.n4 18.4942
R1588 XN.n8 XN.n3 18.4942
R1589 XN.n9 XN.n2 18.4942
R1590 XN.n79 XN.n78 18.4942
R1591 XN.n61 XN.n59 18.4942
R1592 XN.n73 XN.n72 18.4942
R1593 XN.n69 XN.n56 18.4942
R1594 XN.n65 XN.n62 18.4942
R1595 XN.n80 XN.n79 16.6599
R1596 XN.n38 XN.n35 12.6712
R1597 XN.n24 XN.n23 11.6805
R1598 XN.n25 XN.n24 11.6805
R1599 XN.n11 XN.n0 11.6805
R1600 XN.n11 XN.n10 11.6805
R1601 XN.n7 XN.n6 11.6805
R1602 XN.n8 XN.n7 11.6805
R1603 XN.n9 XN.n8 11.6805
R1604 XN.n10 XN.n9 11.6805
R1605 XN.n78 XN.n77 11.6805
R1606 XN.n72 XN.n69 11.6805
R1607 XN.n72 XN.n58 11.6805
R1608 XN.n69 XN.n59 11.6805
R1609 XN.n65 XN.n64 11.6805
R1610 XN.n65 XN.n59 11.6805
R1611 XN.n75 XN.n55 10.8396
R1612 XN.n28 XN.n13 10.7748
R1613 XN.n38 XN.n37 9.44001
R1614 XN.n27 XN.n26 9.1385
R1615 XN.n75 XN.n74 9.0005
R1616 XN.n22 XN.n21 7.17687
R1617 XN.n5 XN.n4 7.17687
R1618 XN.n79 XN.n76 7.17687
R1619 XN.n73 XN.n57 7.17687
R1620 XN.n63 XN.n62 7.17687
R1621 XN.n39 XN.n28 6.41789
R1622 XN.n27 XN.n20 6.40336
R1623 XN.n15 XN.t4 5.7796
R1624 XN.n19 XN.t26 5.7796
R1625 XN.n41 XN.t23 5.73764
R1626 XN.n30 XN.t8 5.73764
R1627 XN.n32 XN.t2 5.73764
R1628 XN.n45 XN.t16 5.73764
R1629 XN.n80 XN.n75 5.63193
R1630 XN.n37 XN.t0 5.59012
R1631 XN.n37 XN.n36 5.57485
R1632 XN.n50 XN.n48 5.51014
R1633 XN.n53 XN.n47 5.4154
R1634 XN.n15 XN.n14 5.38537
R1635 XN.n17 XN.n16 5.38537
R1636 XN.n19 XN.n18 5.38537
R1637 XN.n41 XN.n40 5.32067
R1638 XN.n43 XN.n42 5.32067
R1639 XN.n30 XN.n29 5.32067
R1640 XN.n34 XN.n33 5.32067
R1641 XN.n32 XN.n31 5.32067
R1642 XN.n52 XN.n51 5.32067
R1643 XN.n50 XN.n49 5.32067
R1644 XN.n45 XN.n44 5.32067
R1645 XN.n81 XN.n80 4.5005
R1646 XN.n39 XN.n38 4.5005
R1647 XN.n23 XN.n22 4.42851
R1648 XN.n6 XN.n5 4.42851
R1649 XN.n77 XN.n76 4.42851
R1650 XN.n58 XN.n57 4.42851
R1651 XN.n64 XN.n63 4.42851
R1652 XN.n81 XN.n54 3.95267
R1653 XN.n28 XN.n27 2.93193
R1654 XN.n46 XN.n39 1.76137
R1655 XN.n54 XN.n46 1.72224
R1656 XN.n40 XN.t21 0.228
R1657 XN.n40 XN.t22 0.228
R1658 XN.n42 XN.t19 0.228
R1659 XN.n42 XN.t20 0.228
R1660 XN.n29 XN.t28 0.228
R1661 XN.n29 XN.t3 0.228
R1662 XN.n33 XN.t34 0.228
R1663 XN.n33 XN.t33 0.228
R1664 XN.n31 XN.t7 0.228
R1665 XN.n31 XN.t9 0.228
R1666 XN.n47 XN.t15 0.228
R1667 XN.n47 XN.t12 0.228
R1668 XN.n51 XN.t10 0.228
R1669 XN.n51 XN.t13 0.228
R1670 XN.n49 XN.t14 0.228
R1671 XN.n49 XN.t11 0.228
R1672 XN.n48 XN.t24 0.228
R1673 XN.n48 XN.t25 0.228
R1674 XN.n44 XN.t17 0.228
R1675 XN.n44 XN.t18 0.228
R1676 XN.n14 XN.t29 0.20525
R1677 XN.n14 XN.t31 0.20525
R1678 XN.n16 XN.t1 0.20525
R1679 XN.n16 XN.t30 0.20525
R1680 XN.n18 XN.t6 0.20525
R1681 XN.n18 XN.t32 0.20525
R1682 XN.n36 XN.t27 0.20525
R1683 XN.n36 XN.t5 0.20525
R1684 XN.n45 XN.n43 0.189974
R1685 XN.n43 XN.n41 0.189974
R1686 XN.n17 XN.n15 0.189974
R1687 XN.n34 XN.n32 0.189974
R1688 XN.n52 XN.n50 0.189974
R1689 XN.n35 XN.n34 0.166289
R1690 XN.n26 XN.n21 0.1205
R1691 XN.n4 XN.n3 0.1205
R1692 XN.n3 XN.n2 0.1205
R1693 XN.n2 XN.n1 0.1205
R1694 XN.n62 XN.n61 0.1205
R1695 XN.n67 XN.n66 0.1205
R1696 XN.n66 XN.n60 0.1205
R1697 XN.n71 XN.n70 0.1205
R1698 XN.n12 XN.n1 0.114816
R1699 XN.n61 XN.n56 0.114816
R1700 XN.n68 XN.n67 0.114816
R1701 XN.n20 XN.n19 0.0952368
R1702 XN.n20 XN.n17 0.0952368
R1703 XN.n53 XN.n52 0.0952368
R1704 XN.n71 XN.n55 0.0785
R1705 XN.n74 XN.n73 0.0785
R1706 XN XN.n81 0.0396304
R1707 XN.n13 XN.n12 0.0241842
R1708 XN.n35 XN.n30 0.0241842
R1709 XN.n74 XN.n56 0.0241842
R1710 XN.n68 XN.n55 0.0241842
R1711 XP.n8 XP.t57 127.788
R1712 XP.t50 XP.n0 127.668
R1713 XP.t51 XP.n17 127.668
R1714 XP.n16 XP.t52 127.668
R1715 XP.n15 XP.t53 127.668
R1716 XP.t54 XP.n3 127.668
R1717 XP.t55 XP.n9 127.668
R1718 XP.n8 XP.t56 127.668
R1719 XP.n22 XP.t37 113.632
R1720 XP.t57 XP.n6 113.632
R1721 XP.n74 XP.t38 113.632
R1722 XP.n55 XP.t42 113.632
R1723 XP.n23 XP.t36 109.174
R1724 XP.n24 XP.t35 109.174
R1725 XP.n19 XP.t50 109.174
R1726 XP.n18 XP.t51 109.174
R1727 XP.t52 XP.n2 109.174
R1728 XP.t53 XP.n14 109.174
R1729 XP.n4 XP.t54 109.174
R1730 XP.n10 XP.t55 109.174
R1731 XP.t56 XP.n7 109.174
R1732 XP.n77 XP.t41 109.174
R1733 XP.n76 XP.t40 109.174
R1734 XP.n75 XP.t39 109.174
R1735 XP.n64 XP.t49 109.174
R1736 XP.n63 XP.t48 109.174
R1737 XP.n62 XP.t47 109.174
R1738 XP.n53 XP.t46 109.174
R1739 XP.n58 XP.t45 109.174
R1740 XP.n57 XP.t44 109.174
R1741 XP.n56 XP.t43 109.174
R1742 XP.n33 XP.n32 21.4784
R1743 XP.n40 XP.n39 21.4784
R1744 XP.n25 XP.n24 18.4942
R1745 XP.n20 XP.n19 18.4942
R1746 XP.n18 XP.n1 18.4942
R1747 XP.n5 XP.n2 18.4942
R1748 XP.n14 XP.n13 18.4942
R1749 XP.n12 XP.n4 18.4942
R1750 XP.n11 XP.n10 18.4942
R1751 XP.n78 XP.n77 18.4942
R1752 XP.n76 XP.n73 18.4942
R1753 XP.n65 XP.n64 18.4942
R1754 XP.n63 XP.n52 18.4942
R1755 XP.n62 XP.n61 18.4942
R1756 XP.n60 XP.n53 18.4942
R1757 XP.n59 XP.n58 18.4942
R1758 XP.n57 XP.n54 18.4942
R1759 XP.n26 XP.n25 16.2099
R1760 XP.n50 XP.n47 13.287
R1761 XP.n24 XP.n23 11.6805
R1762 XP.n19 XP.n18 11.6805
R1763 XP.n18 XP.n2 11.6805
R1764 XP.n14 XP.n2 11.6805
R1765 XP.n14 XP.n4 11.6805
R1766 XP.n10 XP.n4 11.6805
R1767 XP.n10 XP.n7 11.6805
R1768 XP.n77 XP.n76 11.6805
R1769 XP.n76 XP.n75 11.6805
R1770 XP.n64 XP.n63 11.6805
R1771 XP.n63 XP.n62 11.6805
R1772 XP.n62 XP.n53 11.6805
R1773 XP.n58 XP.n53 11.6805
R1774 XP.n58 XP.n57 11.6805
R1775 XP.n57 XP.n56 11.6805
R1776 XP.n80 XP.n65 11.3628
R1777 XP.n21 XP.n0 11.2176
R1778 XP.n33 XP.n26 9.3918
R1779 XP.n21 XP.n20 9.3785
R1780 XP.n79 XP.n78 9.3785
R1781 XP.n50 XP.n49 8.99001
R1782 XP.n25 XP.n22 7.17687
R1783 XP.n11 XP.n6 7.17687
R1784 XP.n74 XP.n73 7.17687
R1785 XP.n55 XP.n54 7.17687
R1786 XP.n79 XP.n72 6.40336
R1787 XP.n26 XP.n21 6.08193
R1788 XP.n67 XP.t23 5.7796
R1789 XP.n71 XP.t21 5.7796
R1790 XP.n28 XP.t10 5.73764
R1791 XP.n42 XP.t28 5.73764
R1792 XP.n39 XP.t18 5.73764
R1793 XP.n36 XP.t11 5.73764
R1794 XP.n32 XP.t3 5.73764
R1795 XP.n49 XP.t30 5.59012
R1796 XP.n49 XP.n48 5.57485
R1797 XP.n47 XP.t33 5.54817
R1798 XP.n67 XP.n66 5.38537
R1799 XP.n69 XP.n68 5.38537
R1800 XP.n71 XP.n70 5.38537
R1801 XP.n28 XP.n27 5.32067
R1802 XP.n30 XP.n29 5.32067
R1803 XP.n42 XP.n41 5.32067
R1804 XP.n44 XP.n43 5.32067
R1805 XP.n46 XP.n45 5.32067
R1806 XP.n39 XP.n34 5.32067
R1807 XP.n38 XP.n37 5.32067
R1808 XP.n36 XP.n35 5.32067
R1809 XP.n32 XP.n31 5.32067
R1810 XP.n51 XP.n50 4.5005
R1811 XP.n81 XP.n80 4.5005
R1812 XP.n23 XP.n22 4.42851
R1813 XP.n7 XP.n6 4.42851
R1814 XP.n75 XP.n74 4.42851
R1815 XP.n56 XP.n55 4.42851
R1816 XP.n80 XP.n79 2.48193
R1817 XP.n51 XP.n40 2.38746
R1818 XP.n40 XP.n33 1.72224
R1819 XP.n81 XP.n51 1.60485
R1820 XP.n27 XP.t8 0.228
R1821 XP.n27 XP.t9 0.228
R1822 XP.n29 XP.t6 0.228
R1823 XP.n29 XP.t7 0.228
R1824 XP.n41 XP.t25 0.228
R1825 XP.n41 XP.t27 0.228
R1826 XP.n43 XP.t29 0.228
R1827 XP.n43 XP.t24 0.228
R1828 XP.n45 XP.t26 0.228
R1829 XP.n45 XP.t34 0.228
R1830 XP.n34 XP.t16 0.228
R1831 XP.n34 XP.t17 0.228
R1832 XP.n37 XP.t14 0.228
R1833 XP.n37 XP.t15 0.228
R1834 XP.n35 XP.t12 0.228
R1835 XP.n35 XP.t13 0.228
R1836 XP.n31 XP.t4 0.228
R1837 XP.n31 XP.t5 0.228
R1838 XP.n66 XP.t20 0.20525
R1839 XP.n66 XP.t19 0.20525
R1840 XP.n68 XP.t22 0.20525
R1841 XP.n68 XP.t2 0.20525
R1842 XP.n70 XP.t1 0.20525
R1843 XP.n70 XP.t0 0.20525
R1844 XP.n48 XP.t31 0.20525
R1845 XP.n48 XP.t32 0.20525
R1846 XP.n32 XP.n30 0.189974
R1847 XP.n30 XP.n28 0.189974
R1848 XP.n69 XP.n67 0.189974
R1849 XP.n47 XP.n46 0.189974
R1850 XP.n46 XP.n44 0.189974
R1851 XP.n44 XP.n42 0.189974
R1852 XP.n38 XP.n36 0.189974
R1853 XP.n39 XP.n38 0.189974
R1854 XP.n12 XP.n11 0.1205
R1855 XP.n13 XP.n12 0.1205
R1856 XP.n13 XP.n5 0.1205
R1857 XP.n5 XP.n1 0.1205
R1858 XP.n20 XP.n1 0.1205
R1859 XP.n9 XP.n8 0.1205
R1860 XP.n9 XP.n3 0.1205
R1861 XP.n15 XP.n3 0.1205
R1862 XP.n16 XP.n15 0.1205
R1863 XP.n17 XP.n16 0.1205
R1864 XP.n17 XP.n0 0.1205
R1865 XP.n78 XP.n73 0.1205
R1866 XP.n65 XP.n52 0.1205
R1867 XP.n61 XP.n52 0.1205
R1868 XP.n61 XP.n60 0.1205
R1869 XP.n60 XP.n59 0.1205
R1870 XP.n59 XP.n54 0.1205
R1871 XP.n72 XP.n71 0.0952368
R1872 XP.n72 XP.n69 0.0952368
R1873 XP XP.n81 0.0396304
R1874 VREGN.n14 VREGN.n6 11.1284
R1875 VREGN.n14 VREGN.n13 8.37084
R1876 VREGN.n1 VREGN.t7 5.73764
R1877 VREGN.n3 VREGN.t0 5.73764
R1878 VREGN.n9 VREGN.n7 5.51014
R1879 VREGN.n13 VREGN.n12 5.32067
R1880 VREGN.n11 VREGN.n10 5.32067
R1881 VREGN.n9 VREGN.n8 5.32067
R1882 VREGN.n1 VREGN.n0 5.32067
R1883 VREGN.n5 VREGN.n4 5.32067
R1884 VREGN.n3 VREGN.n2 5.32067
R1885 VREGN VREGN.n14 4.53963
R1886 VREGN.n12 VREGN.t14 0.228
R1887 VREGN.n12 VREGN.t15 0.228
R1888 VREGN.n10 VREGN.t12 0.228
R1889 VREGN.n10 VREGN.t13 0.228
R1890 VREGN.n8 VREGN.t10 0.228
R1891 VREGN.n8 VREGN.t11 0.228
R1892 VREGN.n7 VREGN.t8 0.228
R1893 VREGN.n7 VREGN.t9 0.228
R1894 VREGN.n0 VREGN.t5 0.228
R1895 VREGN.n0 VREGN.t6 0.228
R1896 VREGN.n4 VREGN.t3 0.228
R1897 VREGN.n4 VREGN.t4 0.228
R1898 VREGN.n2 VREGN.t1 0.228
R1899 VREGN.n2 VREGN.t2 0.228
R1900 VREGN.n5 VREGN.n3 0.189974
R1901 VREGN.n11 VREGN.n9 0.189974
R1902 VREGN.n13 VREGN.n11 0.189974
R1903 VREGN.n6 VREGN.n5 0.0952368
R1904 VREGN.n6 VREGN.n1 0.0952368
R1905 SB.n20 SB.t14 127.788
R1906 SB.n13 SB.t7 127.788
R1907 SB.t10 SB.n15 127.668
R1908 SB.n20 SB.t13 127.668
R1909 SB.t12 SB.n21 127.668
R1910 SB.n18 SB.t11 127.668
R1911 SB.n13 SB.t8 127.668
R1912 SB.n14 SB.t9 127.668
R1913 SB.t14 SB.n19 113.632
R1914 SB.n11 SB.t7 113.632
R1915 SB.n16 SB.t10 109.174
R1916 SB.t13 SB.n17 109.174
R1917 SB.n22 SB.t12 109.174
R1918 SB.n23 SB.t11 109.174
R1919 SB.t8 SB.n12 109.174
R1920 SB.t9 SB.n9 109.174
R1921 SB.n4 SB.t0 24.3193
R1922 SB.n16 SB.n7 18.4942
R1923 SB.n22 SB.n8 18.4942
R1924 SB.n24 SB.n23 18.4942
R1925 SB.n10 SB.n9 18.4942
R1926 SB.n5 SB.n4 16.5284
R1927 SB.n2 SB.n0 13.9299
R1928 SB.n23 SB.n22 11.6805
R1929 SB.n22 SB.n17 11.6805
R1930 SB.n23 SB.n16 11.6805
R1931 SB.n12 SB.n9 11.6805
R1932 SB.n16 SB.n9 11.6805
R1933 SB.n5 SB.n2 11.5728
R1934 SB.n26 SB.n6 10.8396
R1935 SB.n4 SB.n3 10.1049
R1936 SB.n26 SB.n25 9.0005
R1937 SB.n19 SB.n8 7.17687
R1938 SB.n11 SB.n10 7.17687
R1939 SB.n27 SB.n26 6.72479
R1940 SB.n27 SB.n5 6.33963
R1941 SB.n1 SB.t2 5.7796
R1942 SB.n0 SB.t5 5.73764
R1943 SB.n1 SB.t1 5.59012
R1944 SB.n0 SB.t6 5.54817
R1945 SB.n2 SB.n1 4.5005
R1946 SB.n19 SB.n17 4.42851
R1947 SB.n12 SB.n11 4.42851
R1948 SB.n3 SB.t4 0.228
R1949 SB.n3 SB.t3 0.228
R1950 SB.n10 SB.n7 0.1205
R1951 SB.n15 SB.n14 0.1205
R1952 SB.n14 SB.n13 0.1205
R1953 SB.n21 SB.n20 0.1205
R1954 SB.n21 SB.n18 0.1205
R1955 SB.n24 SB.n8 0.1205
R1956 SB.n25 SB.n7 0.0485
R1957 SB.n15 SB.n6 0.0485
R1958 SB.n18 SB.n6 0.0485
R1959 SB.n25 SB.n24 0.0485
R1960 SB SB.n27 0.0396304
R1961 SA.n14 SA.t14 127.788
R1962 SA.n7 SA.t7 127.788
R1963 SA.t10 SA.n9 127.668
R1964 SA.n14 SA.t13 127.668
R1965 SA.t12 SA.n15 127.668
R1966 SA.n12 SA.t11 127.668
R1967 SA.n7 SA.t8 127.668
R1968 SA.n8 SA.t9 127.668
R1969 SA.t14 SA.n13 113.632
R1970 SA.n5 SA.t7 113.632
R1971 SA.n10 SA.t10 109.174
R1972 SA.t13 SA.n11 109.174
R1973 SA.n16 SA.t12 109.174
R1974 SA.n17 SA.t11 109.174
R1975 SA.t8 SA.n6 109.174
R1976 SA.t9 SA.n3 109.174
R1977 SA.n22 SA.t0 22.3095
R1978 SA.n23 SA.n22 19.0355
R1979 SA.n10 SA.n1 18.4942
R1980 SA.n16 SA.n2 18.4942
R1981 SA.n18 SA.n17 18.4942
R1982 SA.n4 SA.n3 18.4942
R1983 SA.n26 SA.n24 14.1193
R1984 SA.n23 SA.n20 13.5922
R1985 SA.n17 SA.n16 11.6805
R1986 SA.n16 SA.n11 11.6805
R1987 SA.n17 SA.n10 11.6805
R1988 SA.n6 SA.n3 11.6805
R1989 SA.n10 SA.n3 11.6805
R1990 SA.n20 SA.n0 10.8396
R1991 SA.n27 SA.n26 9.71407
R1992 SA.n20 SA.n19 9.0005
R1993 SA.n13 SA.n2 7.17687
R1994 SA.n5 SA.n4 7.17687
R1995 SA.n25 SA.t2 5.7796
R1996 SA.n21 SA.t4 5.73764
R1997 SA.n24 SA.t6 5.73764
R1998 SA.n25 SA.t1 5.59012
R1999 SA.n21 SA.t3 5.54817
R2000 SA.n24 SA.t5 5.54817
R2001 SA.n22 SA.n21 4.73734
R2002 SA.n26 SA.n25 4.5005
R2003 SA.n13 SA.n11 4.42851
R2004 SA.n6 SA.n5 4.42851
R2005 SA.n27 SA.n23 2.54398
R2006 SA.n4 SA.n1 0.1205
R2007 SA.n9 SA.n8 0.1205
R2008 SA.n8 SA.n7 0.1205
R2009 SA.n15 SA.n14 0.1205
R2010 SA.n15 SA.n12 0.1205
R2011 SA.n18 SA.n2 0.1205
R2012 SA.n19 SA.n1 0.0485
R2013 SA.n9 SA.n0 0.0485
R2014 SA.n12 SA.n0 0.0485
R2015 SA.n19 SA.n18 0.0485
R2016 SA SA.n27 0.0396304
R2017 VREGP.n14 VREGP.n6 16.4697
R2018 VREGP.n14 VREGP.n13 12.6577
R2019 VREGP.n1 VREGP.t7 5.73764
R2020 VREGP.n5 VREGP.t0 5.73764
R2021 VREGP.n9 VREGP.n7 5.51014
R2022 VREGP.n9 VREGP.n8 5.32067
R2023 VREGP.n11 VREGP.n10 5.32067
R2024 VREGP.n13 VREGP.n12 5.32067
R2025 VREGP.n1 VREGP.n0 5.32067
R2026 VREGP.n3 VREGP.n2 5.32067
R2027 VREGP.n5 VREGP.n4 5.32067
R2028 VREGP.n7 VREGP.t14 0.228
R2029 VREGP.n7 VREGP.t15 0.228
R2030 VREGP.n8 VREGP.t12 0.228
R2031 VREGP.n8 VREGP.t13 0.228
R2032 VREGP.n10 VREGP.t10 0.228
R2033 VREGP.n10 VREGP.t11 0.228
R2034 VREGP.n12 VREGP.t8 0.228
R2035 VREGP.n12 VREGP.t9 0.228
R2036 VREGP.n0 VREGP.t5 0.228
R2037 VREGP.n0 VREGP.t6 0.228
R2038 VREGP.n2 VREGP.t3 0.228
R2039 VREGP.n2 VREGP.t4 0.228
R2040 VREGP.n4 VREGP.t1 0.228
R2041 VREGP.n4 VREGP.t2 0.228
R2042 VREGP.n3 VREGP.n1 0.189974
R2043 VREGP.n13 VREGP.n11 0.189974
R2044 VREGP.n11 VREGP.n9 0.189974
R2045 VREGP.n6 VREGP.n5 0.0952368
R2046 VREGP.n6 VREGP.n3 0.0952368
R2047 VREGP VREGP.n14 0.0396304
C0 OUTN VDD 11.6793f
C1 REGEN_CLKB SENSE_CLK 0.01888f
C2 INP INN 3.92748f
C3 SA XP 2.75504f
C4 VDD BP 6.76837f
C5 INN SENSE_CLK 4.83441f
C6 SA VDD 7.15633f
C7 SA NREGEN 2.62097f
C8 INP SA 0.90873f
C9 REGEN_CLKB SXP 0.14644f
C10 OUTP BP 2.97395f
C11 SA SENSE_CLK 2.78252f
C12 NTAIL REGEN_CLK 0.05461f
C13 BP SXP 2.48339f
C14 VREGP XP 9.69939f
C15 SB XP 2.02624f
C16 VREGP VDD 13.9212f
C17 SB VDD 6.4361f
C18 VREGP NREGEN 0.01091f
C19 SB NREGEN 2.22508f
C20 NTAIL SENSE_BOOST_CLK 0.96944f
C21 BN REGEN_CLK 0.12159f
C22 SXN XP 0.18968f
C23 XN REGEN_CLK 2.93387f
C24 INP SB 0.04213f
C25 XN VREGN 9.76051f
C26 SXN VDD 12.5413f
C27 INN NTAIL 1.30545f
C28 SXN NREGEN 1.12793f
C29 SB SENSE_CLK 1.27971f
C30 REGEN_CLKB REGEN_CLK 5.87024f
C31 REGEN_CLKB VREGN 2.28169f
C32 VDD XP 24.8188f
C33 NREGEN XP 15.5907f
C34 BN REGEN_CLKB 0.10264f
C35 NTAIL SA 3.62199f
C36 VDD NREGEN 9.02169f
C37 REGEN_CLKB XN 0.27371f
C38 VREGP SXP 0.03789f
C39 SB SXP 0.01479f
C40 OUTN REGEN_CLK 0.28385f
C41 SENSE_CLK XP 0.15824f
C42 INP NREGEN 0.0139f
C43 OUTN BN 3.20364f
C44 OUTP VDD 11.5691f
C45 VDD SENSE_CLK 3.1142f
C46 NREGEN SENSE_CLK 0.11224f
C47 SA REGEN_CLK 0.34023f
C48 INP SENSE_CLK 0.30281f
C49 SA XN 2.02785f
C50 OUTN REGEN_CLKB 0.19768f
C51 SXP XP 2.28757f
C52 VDD SXP 12.5687f
C53 NREGEN SXP 0.43552f
C54 SA SENSE_BOOST_CLK 0.04435f
C55 SA REGEN_CLKB 0.23634f
C56 NTAIL SB 2.81419f
C57 VDD CAPTURE_CLK 0.11499f
C58 INN SA 0.05427f
C59 SB REGEN_CLK 0.27286f
C60 VREGP XN 1.41685f
C61 SB XN 3.3005f
C62 SXN REGEN_CLK 0.28429f
C63 NTAIL NREGEN 0.05705f
C64 SXN VREGN 0.01502f
C65 SXN BN 2.55502f
C66 SB SENSE_BOOST_CLK 0.17061f
C67 VREGP REGEN_CLKB 3.66341f
C68 INP NTAIL 1.1378f
C69 SB REGEN_CLKB 0.16909f
C70 SXN XN 1.52306f
C71 REGEN_CLK XP 2.97989f
C72 VREGN XP 1.71293f
C73 NTAIL SENSE_CLK 0.93342f
C74 VDD REGEN_CLK 21.5719f
C75 NREGEN REGEN_CLK 2.24204f
C76 VDD VREGN 12.5819f
C77 INN SB 0.77892f
C78 XN XP 18.0183f
C79 SXN REGEN_CLKB 0.24469f
C80 BN VDD 6.76697f
C81 VDD XN 23.0487f
C82 XN NREGEN 15.2443f
C83 REGEN_CLK SENSE_CLK 0.05769f
C84 CAPTURE_CLKB VDD 0.11035f
C85 REGEN_CLKB XP 0.41303f
C86 VREGP SA 0.01053f
C87 INP XN 0.02387f
C88 SA SB 4.61805f
C89 OUTN SXN 0.13551f
C90 VDD REGEN_CLKB 17.4168f
C91 REGEN_CLKB NREGEN 0.18411f
C92 XN SENSE_CLK 1.26026f
C93 INN XP 0.01394f
C94 INP SENSE_BOOST_CLK 0.06018f
C95 INN NREGEN 0.01317f
C96 REGEN_CLK SXP 0.39898f
C97 SENSE_BOOST_CLK SENSE_CLK 4.27044f
C98 CAPTURE_CLK VSS 0.14336f
C99 CAPTURE_CLKB VSS 0.14751f
C100 SENSE_BOOST_CLK VSS 7.76965f
C101 INN VSS 10.40517f
C102 INP VSS 8.13068f
C103 OUTN VSS 9.55872f
C104 OUTP VSS 9.7944f
C105 SENSE_CLK VSS 10.59524f
C106 REGEN_CLK VSS 13.63236f
C107 REGEN_CLKB VSS 4.43084f
C108 VDD VSS 1.39039p
C109 NTAIL VSS 14.09834f
C110 BN VSS 15.10208f
C111 SXN VSS 12.96782f
C112 SXP VSS 13.11247f
C113 BP VSS 14.72881f
C114 NREGEN VSS 16.31945f
C115 XN VSS 8.1339f
C116 XP VSS 8.86716f
C117 VREGN VSS 0.3112f
C118 SB VSS 9.74534f
C119 SA VSS 10.54459f
C120 VREGP VSS 0.30872f
C121 VREGP.t7 VSS 2.16725f
C122 VREGP.t6 VSS 0.45527f
C123 VREGP.t5 VSS 0.45527f
C124 VREGP.n0 VSS 1.64376f
C125 VREGP.n1 VSS 0.90353f
C126 VREGP.t4 VSS 0.45527f
C127 VREGP.t3 VSS 0.45527f
C128 VREGP.n2 VSS 1.64376f
C129 VREGP.n3 VSS 0.37884f
C130 VREGP.t0 VSS 2.16725f
C131 VREGP.t2 VSS 0.45527f
C132 VREGP.t1 VSS 0.45527f
C133 VREGP.n4 VSS 1.64376f
C134 VREGP.n5 VSS 0.8107f
C135 VREGP.n6 VSS 1.22096f
C136 VREGP.t15 VSS 0.46987f
C137 VREGP.t14 VSS 0.46584f
C138 VREGP.n7 VSS 1.65663f
C139 VREGP.t13 VSS 0.46584f
C140 VREGP.t12 VSS 0.46584f
C141 VREGP.n8 VSS 1.64376f
C142 VREGP.n9 VSS 0.83299f
C143 VREGP.t11 VSS 0.46584f
C144 VREGP.t10 VSS 0.46584f
C145 VREGP.n10 VSS 1.64376f
C146 VREGP.n11 VSS 0.47166f
C147 VREGP.t9 VSS 0.46584f
C148 VREGP.t8 VSS 0.46987f
C149 VREGP.n12 VSS 1.64376f
C150 VREGP.n13 VSS 2.23369f
C151 VREGP.n14 VSS 1.8544f
C152 SA.n0 VSS 0.13809f
C153 SA.n1 VSS 0.0842f
C154 SA.n2 VSS 0.29088f
C155 SA.n3 VSS 0.15412f
C156 SA.n4 VSS 0.29088f
C157 SA.n5 VSS 0.14378f
C158 SA.n6 VSS 0.15412f
C159 SA.n7 VSS 0.42671f
C160 SA.n8 VSS 0.21599f
C161 SA.n9 VSS 0.20026f
C162 SA.n10 VSS 0.15412f
C163 SA.n11 VSS 0.15412f
C164 SA.n12 VSS 0.20026f
C165 SA.n13 VSS 0.14378f
C166 SA.n14 VSS 0.42671f
C167 SA.n15 VSS 0.21599f
C168 SA.n16 VSS 0.15412f
C169 SA.n17 VSS 0.15412f
C170 SA.n18 VSS 0.0842f
C171 SA.n19 VSS 0.06995f
C172 SA.n20 VSS 1.72964f
C173 SA.t0 VSS 2.08415f
C174 SA.t4 VSS 1.2845f
C175 SA.t3 VSS 1.27635f
C176 SA.n21 VSS 0.7351f
C177 SA.n22 VSS 2.83171f
C178 SA.n23 VSS 3.36331f
C179 SA.t6 VSS 1.28453f
C180 SA.t5 VSS 1.27632f
C181 SA.n24 VSS 1.33821f
C182 SA.t2 VSS 1.2372f
C183 SA.t1 VSS 1.22902f
C184 SA.n25 VSS 0.49115f
C185 SA.n26 VSS 1.53758f
C186 SA.n27 VSS 0.73939f
C187 SB.t5 VSS 1.23103f
C188 SB.t6 VSS 1.22327f
C189 SB.n0 VSS 1.08885f
C190 SB.t2 VSS 1.22583f
C191 SB.t1 VSS 1.21803f
C192 SB.n1 VSS 0.46776f
C193 SB.n2 VSS 1.54682f
C194 SB.t0 VSS 2.07898f
C195 SB.t3 VSS 0.32952f
C196 SB.t4 VSS 0.32956f
C197 SB.n3 VSS 1.07035f
C198 SB.n4 VSS 2.88511f
C199 SB.n5 VSS 2.80214f
C200 SB.n6 VSS 0.13151f
C201 SB.n7 VSS 0.08019f
C202 SB.n8 VSS 0.27702f
C203 SB.n9 VSS 0.14677f
C204 SB.n10 VSS 0.27702f
C205 SB.n11 VSS 0.13693f
C206 SB.n12 VSS 0.14677f
C207 SB.n13 VSS 0.40638f
C208 SB.n14 VSS 0.2057f
C209 SB.n15 VSS 0.19072f
C210 SB.n16 VSS 0.14677f
C211 SB.n17 VSS 0.14677f
C212 SB.n18 VSS 0.19072f
C213 SB.n19 VSS 0.13693f
C214 SB.n20 VSS 0.40638f
C215 SB.n21 VSS 0.2057f
C216 SB.n22 VSS 0.14677f
C217 SB.n23 VSS 0.14677f
C218 SB.n24 VSS 0.08019f
C219 SB.n25 VSS 0.06662f
C220 SB.n26 VSS 0.97747f
C221 SB.n27 VSS 1.27131f
C222 VREGN.t7 VSS 2.04982f
C223 VREGN.t6 VSS 0.43744f
C224 VREGN.t5 VSS 0.43744f
C225 VREGN.n0 VSS 1.55147f
C226 VREGN.n1 VSS 0.76518f
C227 VREGN.t0 VSS 2.05351f
C228 VREGN.t2 VSS 0.43744f
C229 VREGN.t1 VSS 0.43744f
C230 VREGN.n2 VSS 1.55147f
C231 VREGN.n3 VSS 0.8528f
C232 VREGN.t4 VSS 0.43744f
C233 VREGN.t3 VSS 0.43744f
C234 VREGN.n4 VSS 1.55147f
C235 VREGN.n5 VSS 0.35757f
C236 VREGN.n6 VSS 0.70756f
C237 VREGN.t9 VSS 0.44346f
C238 VREGN.t8 VSS 0.44737f
C239 VREGN.n7 VSS 1.56362f
C240 VREGN.t11 VSS 0.44346f
C241 VREGN.t10 VSS 0.44346f
C242 VREGN.n8 VSS 1.55147f
C243 VREGN.n9 VSS 0.78622f
C244 VREGN.t13 VSS 0.44346f
C245 VREGN.t12 VSS 0.44346f
C246 VREGN.n10 VSS 1.55147f
C247 VREGN.n11 VSS 0.44518f
C248 VREGN.t15 VSS 0.44346f
C249 VREGN.t14 VSS 0.44346f
C250 VREGN.n12 VSS 1.55147f
C251 VREGN.n13 VSS 1.4747f
C252 VREGN.n14 VSS 1.97721f
C253 XP.n0 VSS 0.75743f
C254 XP.n1 VSS 0.13162f
C255 XP.n2 VSS 0.20298f
C256 XP.n3 VSS 0.28447f
C257 XP.n4 VSS 0.20298f
C258 XP.n5 VSS 0.13162f
C259 XP.n6 VSS 0.18936f
C260 XP.n7 VSS 0.20298f
C261 XP.n8 VSS 0.562f
C262 XP.n9 VSS 0.28447f
C263 XP.n10 VSS 0.20298f
C264 XP.n11 VSS 0.38311f
C265 XP.n12 VSS 0.13162f
C266 XP.n13 VSS 0.13162f
C267 XP.n14 VSS 0.20298f
C268 XP.n15 VSS 0.28447f
C269 XP.n16 VSS 0.28447f
C270 XP.n17 VSS 0.28447f
C271 XP.n18 VSS 0.20298f
C272 XP.n19 VSS 0.19184f
C273 XP.n20 VSS 0.51601f
C274 XP.n21 VSS 1.57338f
C275 XP.n22 VSS 0.18936f
C276 XP.n23 VSS 0.20298f
C277 XP.n24 VSS 0.19184f
C278 XP.n25 VSS 0.96466f
C279 XP.n26 VSS 2.41464f
C280 XP.t10 VSS 1.58331f
C281 XP.t9 VSS 0.33383f
C282 XP.t8 VSS 0.33383f
C283 XP.n27 VSS 1.19966f
C284 XP.n28 VSS 0.65942f
C285 XP.t7 VSS 0.33383f
C286 XP.t6 VSS 0.33383f
C287 XP.n29 VSS 1.19966f
C288 XP.n30 VSS 0.34423f
C289 XP.t3 VSS 1.58053f
C290 XP.t5 VSS 0.33383f
C291 XP.t4 VSS 0.33383f
C292 XP.n31 VSS 1.19966f
C293 XP.n32 VSS 1.91833f
C294 XP.n33 VSS 3.62399f
C295 XP.t18 VSS 1.58053f
C296 XP.t17 VSS 0.33383f
C297 XP.t16 VSS 0.33383f
C298 XP.n34 VSS 1.19966f
C299 XP.t11 VSS 1.58331f
C300 XP.t13 VSS 0.33383f
C301 XP.t12 VSS 0.33383f
C302 XP.n35 VSS 1.19966f
C303 XP.n36 VSS 0.65942f
C304 XP.t15 VSS 0.33383f
C305 XP.t14 VSS 0.33383f
C306 XP.n37 VSS 1.19966f
C307 XP.n38 VSS 0.34423f
C308 XP.n39 VSS 1.91833f
C309 XP.n40 VSS 2.33527f
C310 XP.t28 VSS 1.63078f
C311 XP.t27 VSS 0.38004f
C312 XP.t25 VSS 0.38004f
C313 XP.n41 VSS 1.19966f
C314 XP.n42 VSS 0.65942f
C315 XP.t24 VSS 0.38004f
C316 XP.t29 VSS 0.38004f
C317 XP.n43 VSS 1.19966f
C318 XP.n44 VSS 0.34423f
C319 XP.t34 VSS 0.38004f
C320 XP.t26 VSS 0.38004f
C321 XP.n45 VSS 1.19966f
C322 XP.n46 VSS 0.34423f
C323 XP.t33 VSS 1.62002f
C324 XP.n47 VSS 1.13469f
C325 XP.t32 VSS 0.435f
C326 XP.t31 VSS 0.435f
C327 XP.n48 VSS 1.2004f
C328 XP.t30 VSS 1.67197f
C329 XP.n49 VSS 0.90508f
C330 XP.n50 VSS 1.85329f
C331 XP.n51 VSS 1.0456f
C332 XP.n52 VSS 0.13162f
C333 XP.n53 VSS 0.20298f
C334 XP.n54 VSS 0.38311f
C335 XP.n55 VSS 0.18936f
C336 XP.n56 VSS 0.20298f
C337 XP.n57 VSS 0.20298f
C338 XP.n58 VSS 0.20298f
C339 XP.n59 VSS 0.13162f
C340 XP.n60 VSS 0.13162f
C341 XP.n61 VSS 0.13162f
C342 XP.n62 VSS 0.20298f
C343 XP.n63 VSS 0.20298f
C344 XP.n64 VSS 0.19184f
C345 XP.n65 VSS 0.36751f
C346 XP.t23 VSS 1.58237f
C347 XP.t19 VSS 0.3357f
C348 XP.t20 VSS 0.3357f
C349 XP.n66 VSS 1.19081f
C350 XP.n67 VSS 0.67112f
C351 XP.t2 VSS 0.3357f
C352 XP.t22 VSS 0.3357f
C353 XP.n68 VSS 1.19081f
C354 XP.n69 VSS 0.28533f
C355 XP.t21 VSS 1.58237f
C356 XP.t0 VSS 0.3357f
C357 XP.t1 VSS 0.3357f
C358 XP.n70 VSS 1.19081f
C359 XP.n71 VSS 0.60338f
C360 XP.n72 VSS 0.20458f
C361 XP.n73 VSS 0.38311f
C362 XP.n74 VSS 0.18936f
C363 XP.n75 VSS 0.20298f
C364 XP.n76 VSS 0.20298f
C365 XP.n77 VSS 0.19184f
C366 XP.n78 VSS 0.51601f
C367 XP.n79 VSS 0.65345f
C368 XP.n80 VSS 0.71951f
C369 XP.n81 VSS 0.43054f
C370 XN.n0 VSS 0.19839f
C371 XN.n1 VSS 0.13428f
C372 XN.n2 VSS 0.13579f
C373 XN.n3 VSS 0.13579f
C374 XN.n4 VSS 0.39522f
C375 XN.n5 VSS 0.19535f
C376 XN.n6 VSS 0.2094f
C377 XN.n7 VSS 0.2094f
C378 XN.n8 VSS 0.2094f
C379 XN.n9 VSS 0.2094f
C380 XN.n10 VSS 0.2094f
C381 XN.n11 VSS 0.2094f
C382 XN.n12 VSS 0.10621f
C383 XN.n13 VSS 0.25314f
C384 XN.t4 VSS 1.63437f
C385 XN.t31 VSS 0.34822f
C386 XN.t29 VSS 0.34822f
C387 XN.n14 VSS 1.22847f
C388 XN.n15 VSS 0.69235f
C389 XN.t30 VSS 0.34822f
C390 XN.t1 VSS 0.34822f
C391 XN.n16 VSS 1.22847f
C392 XN.n17 VSS 0.29435f
C393 XN.t26 VSS 1.63437f
C394 XN.t32 VSS 0.34822f
C395 XN.t6 VSS 0.34822f
C396 XN.n18 VSS 1.22847f
C397 XN.n19 VSS 0.62246f
C398 XN.n20 VSS 0.21105f
C399 XN.n21 VSS 0.39522f
C400 XN.n22 VSS 0.19535f
C401 XN.n23 VSS 0.2094f
C402 XN.n24 VSS 0.2094f
C403 XN.n25 VSS 0.1979f
C404 XN.n26 VSS 0.3206f
C405 XN.n27 VSS 0.71021f
C406 XN.n28 VSS 0.87854f
C407 XN.t8 VSS 1.66897f
C408 XN.t3 VSS 0.38283f
C409 XN.t28 VSS 0.38283f
C410 XN.n29 VSS 1.2376f
C411 XN.n30 VSS 0.55796f
C412 XN.t2 VSS 1.67287f
C413 XN.t9 VSS 0.38283f
C414 XN.t7 VSS 0.38283f
C415 XN.n31 VSS 1.2376f
C416 XN.n32 VSS 0.68027f
C417 XN.t33 VSS 0.38283f
C418 XN.t34 VSS 0.38283f
C419 XN.n33 VSS 1.2376f
C420 XN.n34 VSS 0.33764f
C421 XN.n35 VSS 0.69915f
C422 XN.t5 VSS 0.4361f
C423 XN.t27 VSS 0.4361f
C424 XN.n36 VSS 1.23836f
C425 XN.t0 VSS 1.71194f
C426 XN.n37 VSS 0.969f
C427 XN.n38 VSS 1.90694f
C428 XN.n39 VSS 1.38561f
C429 XN.t23 VSS 1.63007f
C430 XN.t22 VSS 0.34116f
C431 XN.t21 VSS 0.34116f
C432 XN.n40 VSS 1.2376f
C433 XN.n41 VSS 0.68027f
C434 XN.t20 VSS 0.34116f
C435 XN.t19 VSS 0.34116f
C436 XN.n42 VSS 1.2376f
C437 XN.n43 VSS 0.35512f
C438 XN.t16 VSS 1.62729f
C439 XN.t18 VSS 0.34116f
C440 XN.t17 VSS 0.34116f
C441 XN.n44 VSS 1.2376f
C442 XN.n45 VSS 1.93393f
C443 XN.n46 VSS 2.19485f
C444 XN.t12 VSS 0.34393f
C445 XN.t15 VSS 0.34116f
C446 XN.n47 VSS 1.2413f
C447 XN.t25 VSS 0.34116f
C448 XN.t24 VSS 0.34116f
C449 XN.n48 VSS 1.24729f
C450 XN.t11 VSS 0.34116f
C451 XN.t14 VSS 0.34116f
C452 XN.n49 VSS 1.2376f
C453 XN.n50 VSS 0.62716f
C454 XN.t13 VSS 0.34116f
C455 XN.t10 VSS 0.34116f
C456 XN.n51 VSS 1.2376f
C457 XN.n52 VSS 0.28523f
C458 XN.n53 VSS 1.39559f
C459 XN.n54 VSS 2.58108f
C460 XN.n55 VSS 0.18804f
C461 XN.n56 VSS 0.10621f
C462 XN.n57 VSS 0.19535f
C463 XN.n58 VSS 0.2094f
C464 XN.n59 VSS 0.2094f
C465 XN.n60 VSS 0.57977f
C466 XN.n61 VSS 0.13428f
C467 XN.n62 VSS 0.39522f
C468 XN.n63 VSS 0.19535f
C469 XN.n64 VSS 0.2094f
C470 XN.n65 VSS 0.2094f
C471 XN.n66 VSS 0.29347f
C472 XN.n67 VSS 0.29196f
C473 XN.n68 VSS 0.2639f
C474 XN.n69 VSS 0.2094f
C475 XN.n70 VSS 0.57977f
C476 XN.n71 VSS 0.28137f
C477 XN.n72 VSS 0.2094f
C478 XN.n73 VSS 0.38313f
C479 XN.n74 VSS 0.09546f
C480 XN.n75 VSS 1.55364f
C481 XN.n76 VSS 0.19535f
C482 XN.n77 VSS 0.2094f
C483 XN.n78 VSS 0.1979f
C484 XN.n79 VSS 1.02723f
C485 XN.n80 VSS 1.79458f
C486 XN.n81 VSS 1.07867f
C487 NREGEN.t20 VSS 1.4847f
C488 NREGEN.t19 VSS 1.49452f
C489 NREGEN.n0 VSS 1.51825f
C490 NREGEN.t6 VSS 0.32403f
C491 NREGEN.t31 VSS 0.32107f
C492 NREGEN.n1 VSS 1.09768f
C493 NREGEN.t28 VSS 0.32107f
C494 NREGEN.t30 VSS 0.32107f
C495 NREGEN.n2 VSS 1.08892f
C496 NREGEN.t8 VSS 0.32107f
C497 NREGEN.t24 VSS 0.32403f
C498 NREGEN.n3 VSS 1.09768f
C499 NREGEN.t1 VSS 0.32107f
C500 NREGEN.t33 VSS 0.32107f
C501 NREGEN.n4 VSS 1.08892f
C502 NREGEN.n5 VSS 0.57192f
C503 NREGEN.n6 VSS 0.62125f
C504 NREGEN.n7 VSS 1.92761f
C505 NREGEN.t25 VSS 0.40894f
C506 NREGEN.t0 VSS 0.41272f
C507 NREGEN.n8 VSS 1.09768f
C508 NREGEN.t7 VSS 1.5365f
C509 NREGEN.n9 VSS 0.79737f
C510 NREGEN.n10 VSS 2.26f
C511 NREGEN.t16 VSS 1.49193f
C512 NREGEN.t15 VSS 0.35183f
C513 NREGEN.t14 VSS 0.35183f
C514 NREGEN.n11 VSS 1.08892f
C515 NREGEN.n12 VSS 0.6137f
C516 NREGEN.t13 VSS 0.35183f
C517 NREGEN.t12 VSS 0.35183f
C518 NREGEN.n13 VSS 1.08892f
C519 NREGEN.n14 VSS 0.26092f
C520 NREGEN.t9 VSS 1.49193f
C521 NREGEN.t11 VSS 0.35183f
C522 NREGEN.t10 VSS 0.35183f
C523 NREGEN.n15 VSS 1.08892f
C524 NREGEN.n16 VSS 0.55175f
C525 NREGEN.n17 VSS 0.19669f
C526 NREGEN.n18 VSS 2.0413f
C527 NREGEN.t32 VSS 0.41517f
C528 NREGEN.t26 VSS 0.41907f
C529 NREGEN.n19 VSS 1.09768f
C530 NREGEN.t2 VSS 1.54273f
C531 NREGEN.n20 VSS 0.79737f
C532 NREGEN.n21 VSS 1.23801f
C533 NREGEN.t18 VSS 1.4847f
C534 NREGEN.t17 VSS 1.49452f
C535 NREGEN.n22 VSS 1.51825f
C536 NREGEN.t29 VSS 0.31869f
C537 NREGEN.t21 VSS 0.31587f
C538 NREGEN.n23 VSS 1.09768f
C539 NREGEN.t22 VSS 0.31587f
C540 NREGEN.t5 VSS 0.31587f
C541 NREGEN.n24 VSS 1.08892f
C542 NREGEN.t4 VSS 0.31587f
C543 NREGEN.t23 VSS 0.31869f
C544 NREGEN.n25 VSS 1.09768f
C545 NREGEN.t27 VSS 0.31587f
C546 NREGEN.t3 VSS 0.31587f
C547 NREGEN.n26 VSS 1.08892f
C548 NREGEN.n27 VSS 0.57192f
C549 NREGEN.n28 VSS 0.62125f
C550 NREGEN.n29 VSS 1.81724f
C551 NREGEN.n30 VSS 0.46869f
C552 BP.t9 VSS 0.77482f
C553 BP.t8 VSS 0.77005f
C554 BP.n0 VSS 0.37042f
C555 BP.t7 VSS 0.77356f
C556 BP.t6 VSS 0.22046f
C557 BP.t5 VSS 0.22046f
C558 BP.n1 VSS 0.52735f
C559 BP.n2 VSS 0.29721f
C560 BP.t4 VSS 0.22046f
C561 BP.t3 VSS 0.22046f
C562 BP.n3 VSS 0.52735f
C563 BP.n4 VSS 0.12636f
C564 BP.t0 VSS 0.77356f
C565 BP.t2 VSS 0.22046f
C566 BP.t1 VSS 0.22046f
C567 BP.n5 VSS 0.52735f
C568 BP.n6 VSS 0.26721f
C569 BP.n7 VSS 0.13242f
C570 BP.n8 VSS 0.57561f
C571 BP.n9 VSS 0.04911f
C572 BP.n10 VSS 0.16966f
C573 BP.n11 VSS 0.08386f
C574 BP.n12 VSS 0.08989f
C575 BP.n13 VSS 0.08989f
C576 BP.n14 VSS 0.08989f
C577 BP.n15 VSS 0.08386f
C578 BP.n16 VSS 0.16966f
C579 BP.n17 VSS 0.08989f
C580 BP.n18 VSS 0.08989f
C581 BP.n19 VSS 0.08989f
C582 BP.n20 VSS 0.04911f
C583 BP.n21 VSS 0.05215f
C584 BP.n22 VSS 0.05829f
C585 BP.n23 VSS 0.05829f
C586 BP.n24 VSS 0.16966f
C587 BP.n25 VSS 0.08386f
C588 BP.n26 VSS 0.08989f
C589 BP.n27 VSS 0.08989f
C590 BP.n28 VSS 0.08989f
C591 BP.n29 VSS 0.08989f
C592 BP.n30 VSS 0.08495f
C593 BP.n31 VSS 0.25147f
C594 BP.n32 VSS 0.57788f
C595 BP.n33 VSS 0.34059f
C596 SXP.t5 VSS 1.08502f
C597 SXP.t7 VSS 0.33562f
C598 SXP.t1 VSS 0.33562f
C599 SXP.n0 VSS 0.71748f
C600 SXP.n1 VSS 0.39438f
C601 SXP.t8 VSS 0.33562f
C602 SXP.t2 VSS 0.33562f
C603 SXP.n2 VSS 0.71748f
C604 SXP.n3 VSS 0.20587f
C605 SXP.t4 VSS 0.33562f
C606 SXP.t6 VSS 0.33562f
C607 SXP.n4 VSS 0.71748f
C608 SXP.n5 VSS 0.20587f
C609 SXP.t0 VSS 1.07481f
C610 SXP.n6 VSS 0.5855f
C611 SXP.t10 VSS 1.08331f
C612 SXP.t11 VSS 0.33562f
C613 SXP.t9 VSS 0.33562f
C614 SXP.n7 VSS 0.71219f
C615 SXP.n8 VSS 0.40138f
C616 SXP.t3 VSS 1.07309f
C617 SXP.n9 VSS 0.57887f
C618 SXP.n10 VSS 1.39499f
C619 SXP.n11 VSS 0.44369f
C620 SXP.n12 VSS 0.06633f
C621 SXP.n13 VSS 0.22913f
C622 SXP.n14 VSS 0.11325f
C623 SXP.n15 VSS 0.1214f
C624 SXP.n16 VSS 0.1214f
C625 SXP.n17 VSS 0.1214f
C626 SXP.n18 VSS 0.11325f
C627 SXP.n19 VSS 0.22913f
C628 SXP.n20 VSS 0.1214f
C629 SXP.n21 VSS 0.1214f
C630 SXP.n22 VSS 0.1214f
C631 SXP.n23 VSS 0.06633f
C632 SXP.n24 VSS 0.07275f
C633 SXP.n25 VSS 0.88687f
C634 SXP.n26 VSS 1.78078f
C635 SXN.n0 VSS 0.42389f
C636 SXN.n1 VSS 0.06537f
C637 SXN.n2 VSS 0.22584f
C638 SXN.n3 VSS 0.11163f
C639 SXN.n4 VSS 0.11965f
C640 SXN.n5 VSS 0.11965f
C641 SXN.n6 VSS 0.11965f
C642 SXN.n7 VSS 0.11163f
C643 SXN.n8 VSS 0.22584f
C644 SXN.n9 VSS 0.11965f
C645 SXN.n10 VSS 0.11965f
C646 SXN.n11 VSS 0.11965f
C647 SXN.n12 VSS 0.06537f
C648 SXN.n13 VSS 0.08065f
C649 SXN.n14 VSS 1.52553f
C650 SXN.t1 VSS 1.077f
C651 SXN.t4 VSS 0.33986f
C652 SXN.t3 VSS 0.33986f
C653 SXN.n15 VSS 0.70198f
C654 SXN.n16 VSS 0.39562f
C655 SXN.t5 VSS 1.06675f
C656 SXN.n17 VSS 0.93086f
C657 SXN.n18 VSS 1.75961f
C658 SXN.t6 VSS 1.07869f
C659 SXN.t10 VSS 0.33986f
C660 SXN.t8 VSS 0.33986f
C661 SXN.n19 VSS 0.70719f
C662 SXN.n20 VSS 0.38872f
C663 SXN.t7 VSS 0.33986f
C664 SXN.t11 VSS 0.33986f
C665 SXN.n21 VSS 0.70719f
C666 SXN.n22 VSS 0.20292f
C667 SXN.t0 VSS 0.33986f
C668 SXN.t2 VSS 0.33986f
C669 SXN.n23 VSS 0.70719f
C670 SXN.n24 VSS 0.20292f
C671 SXN.t9 VSS 1.06845f
C672 SXN.n25 VSS 0.90217f
C673 SXN.n26 VSS 0.5459f
C674 BN.n0 VSS 0.05092f
C675 BN.n1 VSS 0.17589f
C676 BN.n2 VSS 0.08694f
C677 BN.n3 VSS 0.09319f
C678 BN.n4 VSS 0.09319f
C679 BN.n5 VSS 0.09319f
C680 BN.n6 VSS 0.08694f
C681 BN.n7 VSS 0.17589f
C682 BN.n8 VSS 0.09319f
C683 BN.n9 VSS 0.09319f
C684 BN.n10 VSS 0.09319f
C685 BN.n11 VSS 0.05092f
C686 BN.n12 VSS 0.04865f
C687 BN.n13 VSS 0.06043f
C688 BN.n14 VSS 0.09319f
C689 BN.n15 VSS 0.09319f
C690 BN.n16 VSS 0.08694f
C691 BN.n17 VSS 0.17589f
C692 BN.n18 VSS 0.06043f
C693 BN.n19 VSS 0.09319f
C694 BN.n20 VSS 0.09319f
C695 BN.n21 VSS 0.08807f
C696 BN.n22 VSS 0.27422f
C697 BN.n23 VSS 0.66526f
C698 BN.t6 VSS 0.79713f
C699 BN.t4 VSS 0.79219f
C700 BN.n24 VSS 0.36943f
C701 BN.t9 VSS 0.79583f
C702 BN.t2 VSS 0.22254f
C703 BN.t3 VSS 0.22254f
C704 BN.n25 VSS 0.54671f
C705 BN.n26 VSS 0.30812f
C706 BN.t0 VSS 0.22254f
C707 BN.t1 VSS 0.22254f
C708 BN.n27 VSS 0.54671f
C709 BN.n28 VSS 0.131f
C710 BN.t5 VSS 0.79583f
C711 BN.t7 VSS 0.22254f
C712 BN.t8 VSS 0.22254f
C713 BN.n29 VSS 0.54671f
C714 BN.n30 VSS 0.27702f
C715 BN.n31 VSS 0.15187f
C716 BN.n32 VSS 0.54133f
C717 BN.n33 VSS 0.40957f
C718 NTAIL.t1 VSS 0.27948f
C719 NTAIL.t0 VSS 0.27948f
C720 NTAIL.n0 VSS 0.97526f
C721 NTAIL.t5 VSS 0.93022f
C722 NTAIL.t4 VSS 0.92461f
C723 NTAIL.n1 VSS 0.44321f
C724 NTAIL.n2 VSS 1.31879f
C725 NTAIL.t11 VSS 0.85034f
C726 NTAIL.t10 VSS 0.20274f
C727 NTAIL.t9 VSS 0.20274f
C728 NTAIL.n3 VSS 0.61999f
C729 NTAIL.n4 VSS 0.34942f
C730 NTAIL.t8 VSS 0.20274f
C731 NTAIL.t7 VSS 0.20274f
C732 NTAIL.n5 VSS 0.61999f
C733 NTAIL.n6 VSS 0.14856f
C734 NTAIL.t6 VSS 0.84857f
C735 NTAIL.n7 VSS 0.31063f
C736 NTAIL.n8 VSS 0.62412f
C737 NTAIL.t2 VSS 0.23749f
C738 NTAIL.t3 VSS 0.23749f
C739 NTAIL.n9 VSS 0.90948f
C740 NTAIL.n10 VSS 0.53201f
C741 VSS.t19 VSS 0.08725f
C742 VSS.t21 VSS 0.08725f
C743 VSS.t9 VSS 0.08725f
C744 VSS.t11 VSS 0.08892f
C745 VSS.t34 VSS 0.08725f
C746 VSS.t36 VSS 0.08725f
C747 VSS.t96 VSS 0.12009f
C748 VSS.t98 VSS 0.11783f
C749 VSS.t92 VSS 0.11783f
C750 VSS.t94 VSS 0.12009f
C751 VSS.t40 VSS 0.11783f
C752 VSS.t42 VSS 0.11783f
C753 VSS.t88 VSS 0.11783f
C754 VSS.t90 VSS 0.11783f
C755 VSS.t78 VSS 0.20079f
C756 VSS.t111 VSS 0.19701f
C757 VSS.t74 VSS 0.19701f
C758 VSS.t16 VSS 0.19701f
C759 VSS.t62 VSS 0.14258f
C760 VSS.t60 VSS 0.1399f
C761 VSS.t117 VSS 0.08207f
C762 VSS.t116 VSS 0.08207f
C763 VSS.t113 VSS 0.08207f
C764 VSS.t112 VSS 0.08364f
C765 VSS.t115 VSS 0.08207f
C766 VSS.t114 VSS 0.08207f
C767 VSS.t52 VSS 0.1399f
C768 VSS.t50 VSS 0.14258f
C769 VSS.t54 VSS 0.1399f
C770 VSS.t48 VSS 0.1399f
C771 VSS.t58 VSS 0.1399f
C772 VSS.t56 VSS 0.1399f
C773 VSS.t46 VSS 0.16195f
C774 VSS.t44 VSS 0.16195f
C775 VSS.t70 VSS 0.20324f
C776 VSS.t68 VSS 0.20324f
C777 VSS.t38 VSS 0.20324f
C778 VSS.t13 VSS 0.20714f
C779 VSS.t119 VSS 0.11836f
C780 VSS.t30 VSS 0.11614f
C781 VSS.t107 VSS 0.11614f
C782 VSS.t85 VSS 0.11836f
C783 VSS.t7 VSS 0.11614f
C784 VSS.t105 VSS 0.11614f
C785 VSS.t32 VSS 0.11614f
C786 VSS.t5 VSS 0.11614f
C787 VSS.t121 VSS 0.09218f
C788 VSS.t123 VSS 0.09045f
C789 VSS.t80 VSS 0.09045f
C790 VSS.t82 VSS 0.09045f
C791 VSS.t64 VSS 0.09045f
C792 VSS.t66 VSS 0.09045f
C793 VDD.n0 VSS 0.28005f
C794 VDD.n1 VSS 0.12652f
C795 VDD.n2 VSS 0.14443f
C796 VDD.n3 VSS 0.13815f
C797 VDD.t43 VSS 0.64471f
C798 VDD.n4 VSS 0.13815f
C799 VDD.n5 VSS 0.14443f
C800 VDD.n6 VSS 0.14724f
C801 VDD.n7 VSS 0.14443f
C802 VDD.n8 VSS 0.13815f
C803 VDD.n9 VSS 6.44709f
C804 VDD.t41 VSS 4.32876f
C805 VDD.n10 VSS 0.38866f
C806 VDD.t7 VSS 0.1842f
C807 VDD.n11 VSS 0.13815f
C808 VDD.n12 VSS 0.14443f
C809 VDD.n13 VSS 0.14724f
C810 VDD.n14 VSS 0.14443f
C811 VDD.n15 VSS 0.13815f
C812 VDD.t85 VSS 0.73681f
C813 VDD.n16 VSS 0.13815f
C814 VDD.n17 VSS 0.14443f
C815 VDD.n18 VSS 0.14724f
C816 VDD.n19 VSS 0.14443f
C817 VDD.n20 VSS 0.13815f
C818 VDD.t96 VSS 2.76304f
C819 VDD.n21 VSS 0.62368f
C820 VDD.n22 VSS 8.81472f
C821 VDD.n23 VSS 0.13815f
C822 VDD.n24 VSS 0.14443f
C823 VDD.n25 VSS 0.12359f
C824 VDD.n26 VSS 0.14443f
C825 VDD.n27 VSS 0.13815f
C826 VDD.n28 VSS 7.05064f
C827 VDD.n29 VSS 4.94072f
C828 VDD.t112 VSS 1.84203f
C829 VDD.t114 VSS 0.73681f
C830 VDD.t163 VSS 0.73681f
C831 VDD.t165 VSS 0.73681f
C832 VDD.t107 VSS 0.73681f
C833 VDD.t109 VSS 0.73681f
C834 VDD.t100 VSS 0.73681f
C835 VDD.t102 VSS 2.76304f
C836 VDD.t98 VSS 4.32876f
C837 VDD.t124 VSS 0.64471f
C838 VDD.n30 VSS 2.67094f
C839 VDD.n31 VSS 0.13815f
C840 VDD.n32 VSS 0.14443f
C841 VDD.n33 VSS 0.3986f
C842 VDD.n34 VSS 0.14724f
C843 VDD.n35 VSS 0.14724f
C844 VDD.n36 VSS 0.14443f
C845 VDD.n37 VSS 0.13815f
C846 VDD.n38 VSS 9.21013f
C847 VDD.n39 VSS 6.44709f
C848 VDD.n40 VSS 4.67017f
C849 VDD.n41 VSS 0.38866f
C850 VDD.n42 VSS 0.38866f
C851 VDD.t52 VSS 0.55261f
C852 VDD.n43 VSS 0.61771f
C853 VDD.t54 VSS 0.55261f
C854 VDD.t66 VSS 0.73681f
C855 VDD.t88 VSS 0.73681f
C856 VDD.t90 VSS 0.55261f
C857 VDD.t14 VSS 0.55261f
C858 VDD.t39 VSS 0.73681f
C859 VDD.t45 VSS 0.73681f
C860 VDD.t175 VSS 0.73681f
C861 VDD.t170 VSS 0.73681f
C862 VDD.t162 VSS 0.73681f
C863 VDD.t15 VSS 0.73681f
C864 VDD.t40 VSS 0.55261f
C865 VDD.t144 VSS 0.55261f
C866 VDD.t130 VSS 0.73681f
C867 VDD.t148 VSS 0.73681f
C868 VDD.t150 VSS 0.64471f
C869 VDD.t116 VSS 0.3684f
C870 VDD.t154 VSS 0.3684f
C871 VDD.t120 VSS 0.3684f
C872 VDD.t152 VSS 0.3684f
C873 VDD.t126 VSS 0.3684f
C874 VDD.t156 VSS 0.3684f
C875 VDD.t168 VSS 0.3684f
C876 VDD.t158 VSS 0.3684f
C877 VDD.t118 VSS 0.64471f
C878 VDD.t23 VSS 0.73681f
C879 VDD.t5 VSS 0.64471f
C880 VDD.t56 VSS 0.3684f
C881 VDD.t122 VSS 0.1842f
C882 VDD.n44 VSS 0.2763f
C883 VDD.n45 VSS 0.13815f
C884 VDD.n46 VSS 0.14443f
C885 VDD.n47 VSS 0.14724f
C886 VDD.n48 VSS 0.14724f
C887 VDD.n49 VSS 0.14724f
C888 VDD.n50 VSS 0.14443f
C889 VDD.n51 VSS 0.13815f
C890 VDD.t83 VSS 0.73681f
C891 VDD.t81 VSS 1.84203f
C892 VDD.t171 VSS 2.94724f
C893 VDD.t80 VSS 1.84203f
C894 VDD.t79 VSS 0.73681f
C895 VDD.t78 VSS 0.73681f
C896 VDD.t51 VSS 0.55261f
C897 VDD.n52 VSS 0.3684f
C898 VDD.t50 VSS 0.55261f
C899 VDD.t77 VSS 0.73681f
C900 VDD.t76 VSS 0.73681f
C901 VDD.t75 VSS 1.84203f
C902 VDD.t173 VSS 2.94724f
C903 VDD.t73 VSS 1.84203f
C904 VDD.t94 VSS 0.3684f
C905 VDD.t29 VSS 0.64471f
C906 VDD.t25 VSS 0.73681f
C907 VDD.t16 VSS 0.64471f
C908 VDD.t128 VSS 0.3684f
C909 VDD.t105 VSS 0.3684f
C910 VDD.t132 VSS 0.3684f
C911 VDD.t9 VSS 0.3684f
C912 VDD.t134 VSS 0.3684f
C913 VDD.t31 VSS 0.3684f
C914 VDD.t138 VSS 0.3684f
C915 VDD.t27 VSS 0.3684f
C916 VDD.t136 VSS 0.64471f
C917 VDD.t140 VSS 0.73681f
C918 VDD.t142 VSS 0.73681f
C919 VDD.t146 VSS 0.55261f
C920 VDD.t37 VSS 0.55261f
C921 VDD.t22 VSS 0.73681f
C922 VDD.t4 VSS 0.73681f
C923 VDD.t13 VSS 0.73681f
C924 VDD.t38 VSS 0.73681f
C925 VDD.t104 VSS 0.73681f
C926 VDD.t111 VSS 0.73681f
C927 VDD.t167 VSS 0.55261f
C928 VDD.t58 VSS 0.55261f
C929 VDD.t60 VSS 0.73681f
C930 VDD.t63 VSS 0.73681f
C931 VDD.t48 VSS 0.55261f
C932 VDD.n53 VSS 0.61771f
C933 VDD.t46 VSS 0.55261f
C934 VDD.t69 VSS 0.73681f
C935 VDD.t71 VSS 0.73681f
C936 VDD.n54 VSS 0.13815f
C937 VDD.n55 VSS 0.14443f
C938 VDD.n56 VSS 0.14724f
C939 VDD.n57 VSS 0.14724f
C940 VDD.n58 VSS 0.14724f
C941 VDD.n59 VSS 0.14443f
C942 VDD.n60 VSS 0.13815f
C943 VDD.n61 VSS 0.2763f
C944 VDD.t92 VSS 2.76304f
C945 VDD.n62 VSS 4.67017f
C946 VDD.n63 VSS 0.38866f
C947 VDD.n64 VSS 0.38866f
C948 VDD.n65 VSS 8.81472f
C949 VDD.n66 VSS 9.21013f
C950 VDD.n67 VSS 0.13815f
C951 VDD.n68 VSS 0.14443f
C952 VDD.n69 VSS 0.14724f
C953 VDD.n70 VSS 0.14724f
C954 VDD.n71 VSS 0.14724f
C955 VDD.n72 VSS 0.14443f
C956 VDD.n73 VSS 0.13815f
C957 VDD.n74 VSS 2.67094f
C958 VDD.t0 VSS 2.76304f
C959 VDD.t2 VSS 0.73681f
C960 VDD.t18 VSS 0.73681f
C961 VDD.t20 VSS 0.73681f
C962 VDD.t33 VSS 0.73681f
C963 VDD.t35 VSS 0.73681f
C964 VDD.t11 VSS 0.73681f
C965 VDD.t160 VSS 1.84203f
C966 VDD.n75 VSS 4.92264f
C967 VDD.n76 VSS 7.04195f
C968 VDD.n77 VSS 0.11732f
C969 VDD.n78 VSS 0.15635f
C970 VDD.t95 VSS 0.15854f
C971 VDD.t93 VSS 0.15851f
C972 VDD.n79 VSS 0.21332f
C973 VDD.n80 VSS 0.23889f
C974 VDD.n81 VSS 0.08316f
C975 VDD.n82 VSS 0.05516f
C976 VDD.t113 VSS 0.10815f
C977 VDD.t115 VSS 0.10641f
C978 VDD.n83 VSS 0.08623f
C979 VDD.t101 VSS 0.10641f
C980 VDD.t103 VSS 0.10815f
C981 VDD.n84 VSS 0.08328f
C982 VDD.t108 VSS 0.10641f
C983 VDD.t110 VSS 0.10641f
C984 VDD.n85 VSS 0.08264f
C985 VDD.n86 VSS 0.04188f
C986 VDD.t164 VSS 0.10641f
C987 VDD.t166 VSS 0.10641f
C988 VDD.n87 VSS 0.08264f
C989 VDD.n88 VSS 0.20716f
C990 VDD.n89 VSS 0.24501f
C991 VDD.t125 VSS 0.13432f
C992 VDD.t99 VSS 0.13432f
C993 VDD.n90 VSS 0.24357f
C994 VDD.n91 VSS 0.89017f
C995 VDD.t97 VSS 0.15854f
C996 VDD.t57 VSS 0.15851f
C997 VDD.n92 VSS 0.21332f
C998 VDD.n93 VSS 0.22022f
C999 VDD.n94 VSS 0.4114f
C1000 VDD.t123 VSS 0.2192f
C1001 VDD.t6 VSS 0.2192f
C1002 VDD.n95 VSS 0.08264f
C1003 VDD.n96 VSS 0.24379f
C1004 VDD.t24 VSS 0.2192f
C1005 VDD.t119 VSS 0.2192f
C1006 VDD.n97 VSS 0.08264f
C1007 VDD.n98 VSS 0.01788f
C1008 VDD.t121 VSS 0.2192f
C1009 VDD.t117 VSS 0.2231f
C1010 VDD.n99 VSS 0.08328f
C1011 VDD.t169 VSS 0.2192f
C1012 VDD.t127 VSS 0.2192f
C1013 VDD.n100 VSS 0.08264f
C1014 VDD.n101 VSS 0.03838f
C1015 VDD.n102 VSS 0.09154f
C1016 VDD.n103 VSS 0.26471f
C1017 VDD.t159 VSS 0.15374f
C1018 VDD.t157 VSS 0.15368f
C1019 VDD.n104 VSS 0.08264f
C1020 VDD.n105 VSS 0.02329f
C1021 VDD.t131 VSS 0.15368f
C1022 VDD.t145 VSS 0.15742f
C1023 VDD.n106 VSS 0.08328f
C1024 VDD.t151 VSS 0.15368f
C1025 VDD.t149 VSS 0.15368f
C1026 VDD.n107 VSS 0.08264f
C1027 VDD.n108 VSS 0.04188f
C1028 VDD.t153 VSS 0.15368f
C1029 VDD.t155 VSS 0.15368f
C1030 VDD.n109 VSS 0.08264f
C1031 VDD.n110 VSS 0.01904f
C1032 VDD.n111 VSS 0.06215f
C1033 VDD.n112 VSS 0.11348f
C1034 VDD.n113 VSS 0.19432f
C1035 VDD.t55 VSS 0.17793f
C1036 VDD.t53 VSS 0.1779f
C1037 VDD.n114 VSS 0.13686f
C1038 VDD.t91 VSS 0.1208f
C1039 VDD.t89 VSS 0.11803f
C1040 VDD.n115 VSS 0.08264f
C1041 VDD.n116 VSS 0.14324f
C1042 VDD.t67 VSS 0.11803f
C1043 VDD.t68 VSS 0.11803f
C1044 VDD.n117 VSS 0.08264f
C1045 VDD.n118 VSS 0.02371f
C1046 VDD.t87 VSS 0.11803f
C1047 VDD.t86 VSS 0.11803f
C1048 VDD.n119 VSS 0.08264f
C1049 VDD.n120 VSS 0.02371f
C1050 VDD.t84 VSS 0.11803f
C1051 VDD.t82 VSS 0.11803f
C1052 VDD.n121 VSS 0.08264f
C1053 VDD.n122 VSS 0.01881f
C1054 VDD.n123 VSS 0.20573f
C1055 VDD.t172 VSS 0.12594f
C1056 VDD.n124 VSS 0.15873f
C1057 VDD.n125 VSS 0.16949f
C1058 VDD.n126 VSS 0.13216f
C1059 VDD.t47 VSS 0.17793f
C1060 VDD.t49 VSS 0.1779f
C1061 VDD.n127 VSS 0.13686f
C1062 VDD.t174 VSS 0.12594f
C1063 VDD.n128 VSS 0.19012f
C1064 VDD.t61 VSS 0.11803f
C1065 VDD.t59 VSS 0.1208f
C1066 VDD.n129 VSS 0.08328f
C1067 VDD.t62 VSS 0.11803f
C1068 VDD.t64 VSS 0.11803f
C1069 VDD.n130 VSS 0.08264f
C1070 VDD.n131 VSS 0.04188f
C1071 VDD.t70 VSS 0.11803f
C1072 VDD.t65 VSS 0.11803f
C1073 VDD.n132 VSS 0.08264f
C1074 VDD.n133 VSS 0.02371f
C1075 VDD.t74 VSS 0.11803f
C1076 VDD.t72 VSS 0.11803f
C1077 VDD.n134 VSS 0.08264f
C1078 VDD.n135 VSS 0.04533f
C1079 VDD.n136 VSS 0.30109f
C1080 VDD.n137 VSS 0.10482f
C1081 VDD.n138 VSS 0.13993f
C1082 VDD.t147 VSS 0.15742f
C1083 VDD.t143 VSS 0.15368f
C1084 VDD.n139 VSS 0.08264f
C1085 VDD.n140 VSS 0.11518f
C1086 VDD.t141 VSS 0.15368f
C1087 VDD.t137 VSS 0.15368f
C1088 VDD.n141 VSS 0.08264f
C1089 VDD.n142 VSS 0.01904f
C1090 VDD.t133 VSS 0.15368f
C1091 VDD.t129 VSS 0.15742f
C1092 VDD.n143 VSS 0.08328f
C1093 VDD.t139 VSS 0.15368f
C1094 VDD.t135 VSS 0.15368f
C1095 VDD.n144 VSS 0.08264f
C1096 VDD.n145 VSS 0.03721f
C1097 VDD.n147 VSS 0.26507f
C1098 VDD.t28 VSS 0.21675f
C1099 VDD.t32 VSS 0.21297f
C1100 VDD.n148 VSS 0.08264f
C1101 VDD.n149 VSS 0.10748f
C1102 VDD.t10 VSS 0.21297f
C1103 VDD.t106 VSS 0.21297f
C1104 VDD.n150 VSS 0.08264f
C1105 VDD.n151 VSS 0.02371f
C1106 VDD.t17 VSS 0.21297f
C1107 VDD.t26 VSS 0.21297f
C1108 VDD.n152 VSS 0.08264f
C1109 VDD.n153 VSS 0.02371f
C1110 VDD.t30 VSS 0.21297f
C1111 VDD.t8 VSS 0.21297f
C1112 VDD.n154 VSS 0.08264f
C1113 VDD.n155 VSS 0.24379f
C1114 VDD.n156 VSS 0.42074f
C1115 VDD.t42 VSS 0.13604f
C1116 VDD.t44 VSS 0.13604f
C1117 VDD.n157 VSS 0.24357f
C1118 VDD.n158 VSS 0.47536f
C1119 VDD.n159 VSS 0.23595f
C1120 VDD.t1 VSS 0.10488f
C1121 VDD.t3 VSS 0.10321f
C1122 VDD.n160 VSS 0.08264f
C1123 VDD.n161 VSS 0.20226f
C1124 VDD.t12 VSS 0.10321f
C1125 VDD.t161 VSS 0.10488f
C1126 VDD.n162 VSS 0.08328f
C1127 VDD.t34 VSS 0.10321f
C1128 VDD.t36 VSS 0.10321f
C1129 VDD.n163 VSS 0.08264f
C1130 VDD.n164 VSS 0.04188f
C1131 VDD.t19 VSS 0.10321f
C1132 VDD.t21 VSS 0.10321f
C1133 VDD.n165 VSS 0.08264f
C1134 VDD.n166 VSS 0.20716f
C1135 VDD.n167 VSS 0.30318f
C1136 VDD.n168 VSS 0.03911f
C1137 REGEN_CLKB.n0 VSS 0.17425f
C1138 REGEN_CLKB.n1 VSS 0.10625f
C1139 REGEN_CLKB.n2 VSS 0.19447f
C1140 REGEN_CLKB.n3 VSS 0.27255f
C1141 REGEN_CLKB.n4 VSS 0.12611f
C1142 REGEN_CLKB.n5 VSS 0.12611f
C1143 REGEN_CLKB.n6 VSS 0.36705f
C1144 REGEN_CLKB.n7 VSS 0.53845f
C1145 REGEN_CLKB.n8 VSS 0.18143f
C1146 REGEN_CLKB.n9 VSS 0.19447f
C1147 REGEN_CLKB.n10 VSS 0.19447f
C1148 REGEN_CLKB.n11 VSS 0.19447f
C1149 REGEN_CLKB.n12 VSS 0.27255f
C1150 REGEN_CLKB.n13 VSS 0.27255f
C1151 REGEN_CLKB.n14 VSS 0.25269f
C1152 REGEN_CLKB.n15 VSS 0.19447f
C1153 REGEN_CLKB.n16 VSS 0.51859f
C1154 REGEN_CLKB.n17 VSS 0.19447f
C1155 REGEN_CLKB.n18 VSS 0.17885f
C1156 REGEN_CLKB.n19 VSS 0.31193f
C1157 REGEN_CLKB.n20 VSS 3.46143f
C1158 REGEN_CLKB.n21 VSS 0.42042f
C1159 REGEN_CLKB.n22 VSS 0.1841f
C1160 REGEN_CLKB.n23 VSS 0.12611f
C1161 REGEN_CLKB.n24 VSS 0.12611f
C1162 REGEN_CLKB.n25 VSS 0.12611f
C1163 REGEN_CLKB.n26 VSS 0.19447f
C1164 REGEN_CLKB.n27 VSS 0.25269f
C1165 REGEN_CLKB.n28 VSS 0.27255f
C1166 REGEN_CLKB.n29 VSS 0.27255f
C1167 REGEN_CLKB.n30 VSS 0.27255f
C1168 REGEN_CLKB.n31 VSS 0.27255f
C1169 REGEN_CLKB.n32 VSS 0.53845f
C1170 REGEN_CLKB.n33 VSS 0.18143f
C1171 REGEN_CLKB.n34 VSS 0.36705f
C1172 REGEN_CLKB.n35 VSS 0.19447f
C1173 REGEN_CLKB.n36 VSS 0.19447f
C1174 REGEN_CLKB.n37 VSS 0.19447f
C1175 REGEN_CLKB.n38 VSS 0.19447f
C1176 REGEN_CLKB.n39 VSS 0.19447f
C1177 REGEN_CLKB.n40 VSS 0.10625f
C1178 REGEN_CLKB.n41 VSS 0.18781f
C1179 REGEN_CLKB.n42 VSS 2.10672f
C1180 REGEN_CLKB.n43 VSS 8.98982f
C1181 REGEN_CLK.n0 VSS 0.81603f
C1182 REGEN_CLK.n1 VSS 0.40948f
C1183 REGEN_CLK.n2 VSS 0.09347f
C1184 REGEN_CLK.n3 VSS 0.14413f
C1185 REGEN_CLK.n4 VSS 0.202f
C1186 REGEN_CLK.n5 VSS 0.09347f
C1187 REGEN_CLK.n6 VSS 0.09347f
C1188 REGEN_CLK.n7 VSS 0.09347f
C1189 REGEN_CLK.n8 VSS 0.27204f
C1190 REGEN_CLK.n9 VSS 0.202f
C1191 REGEN_CLK.n10 VSS 0.202f
C1192 REGEN_CLK.n11 VSS 0.39907f
C1193 REGEN_CLK.n12 VSS 0.13446f
C1194 REGEN_CLK.n13 VSS 0.14413f
C1195 REGEN_CLK.n14 VSS 0.14413f
C1196 REGEN_CLK.n15 VSS 0.14413f
C1197 REGEN_CLK.n16 VSS 0.14413f
C1198 REGEN_CLK.n17 VSS 0.14413f
C1199 REGEN_CLK.n18 VSS 0.202f
C1200 REGEN_CLK.n19 VSS 0.202f
C1201 REGEN_CLK.n20 VSS 0.31296f
C1202 REGEN_CLK.n21 VSS 0.13622f
C1203 REGEN_CLK.n22 VSS 0.20443f
C1204 REGEN_CLK.n23 VSS 0.09347f
C1205 REGEN_CLK.n24 VSS 0.14413f
C1206 REGEN_CLK.n25 VSS 0.202f
C1207 REGEN_CLK.n26 VSS 0.09347f
C1208 REGEN_CLK.n27 VSS 0.09347f
C1209 REGEN_CLK.n28 VSS 0.09347f
C1210 REGEN_CLK.n29 VSS 0.27204f
C1211 REGEN_CLK.n30 VSS 0.202f
C1212 REGEN_CLK.n31 VSS 0.202f
C1213 REGEN_CLK.n32 VSS 0.39907f
C1214 REGEN_CLK.n33 VSS 0.13446f
C1215 REGEN_CLK.n34 VSS 0.14413f
C1216 REGEN_CLK.n35 VSS 0.14413f
C1217 REGEN_CLK.n36 VSS 0.14413f
C1218 REGEN_CLK.n37 VSS 0.14413f
C1219 REGEN_CLK.n38 VSS 0.14413f
C1220 REGEN_CLK.n39 VSS 0.202f
C1221 REGEN_CLK.n40 VSS 0.202f
C1222 REGEN_CLK.n41 VSS 0.31296f
C1223 REGEN_CLK.n42 VSS 0.13622f
C1224 REGEN_CLK.n43 VSS 0.20443f
C1225 REGEN_CLK.n44 VSS 0.34575f
C1226 REGEN_CLK.n45 VSS 1.0827f
C1227 REGEN_CLK.n46 VSS 0.07875f
C1228 REGEN_CLK.n47 VSS 0.27204f
C1229 REGEN_CLK.n48 VSS 0.13446f
C1230 REGEN_CLK.n49 VSS 0.14413f
C1231 REGEN_CLK.n50 VSS 0.14413f
C1232 REGEN_CLK.n51 VSS 0.14413f
C1233 REGEN_CLK.n52 VSS 0.13446f
C1234 REGEN_CLK.n53 VSS 0.27204f
C1235 REGEN_CLK.n54 VSS 0.14413f
C1236 REGEN_CLK.n55 VSS 0.14413f
C1237 REGEN_CLK.n56 VSS 0.14413f
C1238 REGEN_CLK.n57 VSS 0.07875f
C1239 REGEN_CLK.n58 VSS 0.51565f
C1240 REGEN_CLK.n59 VSS 1.55245f
C1241 REGEN_CLK.n60 VSS 2.56147f
C1242 REGEN_CLK.n61 VSS 0.33713f
C1243 REGEN_CLK.n62 VSS 0.09347f
C1244 REGEN_CLK.n63 VSS 0.09347f
C1245 REGEN_CLK.n64 VSS 0.09347f
C1246 REGEN_CLK.n65 VSS 0.09347f
C1247 REGEN_CLK.n66 VSS 0.27204f
C1248 REGEN_CLK.n67 VSS 0.202f
C1249 REGEN_CLK.n68 VSS 0.202f
C1250 REGEN_CLK.n69 VSS 0.202f
C1251 REGEN_CLK.n70 VSS 0.202f
C1252 REGEN_CLK.n71 VSS 0.202f
C1253 REGEN_CLK.n72 VSS 0.39907f
C1254 REGEN_CLK.n73 VSS 0.13446f
C1255 REGEN_CLK.n74 VSS 0.14413f
C1256 REGEN_CLK.n75 VSS 0.14413f
C1257 REGEN_CLK.n76 VSS 0.14413f
C1258 REGEN_CLK.n77 VSS 0.14413f
C1259 REGEN_CLK.n78 VSS 0.14413f
C1260 REGEN_CLK.n79 VSS 0.14413f
C1261 REGEN_CLK.n80 VSS 0.13622f
C1262 REGEN_CLK.n81 VSS 0.16507f
C1263 REGEN_CLK.n82 VSS 1.27358f
C1264 REGEN_CLK.n83 VSS 1.49761f
C1265 REGEN_CLK.n84 VSS 0.57519f
C1266 REGEN_CLK.n85 VSS 3.84291f
C1267 SENSE_CLK.n0 VSS 0.34647f
C1268 SENSE_CLK.n1 VSS 0.34647f
C1269 SENSE_CLK.n2 VSS 2.16469f
C1270 SENSE_CLK.n3 VSS 0.43345f
C1271 SENSE_CLK.n4 VSS 2.24053f
C1272 SENSE_CLK.n5 VSS 1.63521f
C1273 SENSE_CLK.n6 VSS 6.8957f
C1274 OUTP.t0 VSS 1.15761f
C1275 OUTP.t1 VSS 0.25477f
C1276 OUTP.t5 VSS 0.25477f
C1277 OUTP.n0 VSS 0.86715f
C1278 OUTP.n1 VSS 0.47665f
C1279 OUTP.t6 VSS 0.25477f
C1280 OUTP.t9 VSS 0.25477f
C1281 OUTP.n2 VSS 0.86715f
C1282 OUTP.n3 VSS 0.19985f
C1283 OUTP.t13 VSS 1.15761f
C1284 OUTP.t10 VSS 0.25477f
C1285 OUTP.t2 VSS 0.25477f
C1286 OUTP.n4 VSS 0.86715f
C1287 OUTP.n5 VSS 0.42768f
C1288 OUTP.n6 VSS 0.19421f
C1289 OUTP.t7 VSS 1.14672f
C1290 OUTP.t4 VSS 1.15554f
C1291 OUTP.t12 VSS 0.25477f
C1292 OUTP.t3 VSS 0.25477f
C1293 OUTP.n7 VSS 0.86076f
C1294 OUTP.n8 VSS 0.48511f
C1295 OUTP.t8 VSS 0.25477f
C1296 OUTP.t11 VSS 0.25477f
C1297 OUTP.n9 VSS 0.86076f
C1298 OUTP.n10 VSS 0.24297f
C1299 OUTP.n11 VSS 0.41431f
C1300 OUTP.n12 VSS 1.27687f
C1301 OUTN.t6 VSS 1.20893f
C1302 OUTN.t7 VSS 0.26551f
C1303 OUTN.t10 VSS 0.26551f
C1304 OUTN.n0 VSS 0.90615f
C1305 OUTN.n1 VSS 0.49808f
C1306 OUTN.t11 VSS 0.26551f
C1307 OUTN.t4 VSS 0.26551f
C1308 OUTN.n2 VSS 0.90615f
C1309 OUTN.n3 VSS 0.20884f
C1310 OUTN.t3 VSS 1.20893f
C1311 OUTN.t5 VSS 0.26551f
C1312 OUTN.t2 VSS 0.26551f
C1313 OUTN.n4 VSS 0.90615f
C1314 OUTN.n5 VSS 0.44691f
C1315 OUTN.n6 VSS 0.18132f
C1316 OUTN.t12 VSS 1.20676f
C1317 OUTN.t13 VSS 0.26551f
C1318 OUTN.t0 VSS 0.26551f
C1319 OUTN.n7 VSS 0.89947f
C1320 OUTN.n8 VSS 0.50692f
C1321 OUTN.t1 VSS 0.26551f
C1322 OUTN.t8 VSS 0.26551f
C1323 OUTN.n9 VSS 0.89947f
C1324 OUTN.n10 VSS 0.26669f
C1325 OUTN.t9 VSS 1.19689f
C1326 OUTN.n11 VSS 0.61971f
C1327 OUTN.n12 VSS 1.39758f
C1328 INP.n0 VSS 2.03209f
C1329 INN.n0 VSS 3.60291f
C1330 SENSE_BOOST_CLK.n0 VSS 0.08005f
C1331 SENSE_BOOST_CLK.n1 VSS 0.05483f
C1332 SENSE_BOOST_CLK.n2 VSS 0.08455f
C1333 SENSE_BOOST_CLK.n3 VSS 0.07888f
C1334 SENSE_BOOST_CLK.n4 VSS 0.15959f
C1335 SENSE_BOOST_CLK.n5 VSS 0.08455f
C1336 SENSE_BOOST_CLK.n6 VSS 0.08455f
C1337 SENSE_BOOST_CLK.n7 VSS 0.08455f
C1338 SENSE_BOOST_CLK.n8 VSS 0.0462f
C1339 SENSE_BOOST_CLK.n9 VSS 1.42741f
.ends
