* PEX produced using /foss/tools/sak/sak-pex.sh with m=3 and s=1 (extresist threshold=0 mOhm, minres=1 mOhm, mindelay=0 ps)
* NGSPICE file created from deserializer_split_capture_pex.ext - technology: gf180mcuD

.subckt deserializer_split_capture_pex EVEN_D EVEN_DB ODD_D ODD_DB EVEN_CAPTURE_CLK
+ EVEN_CAPTURE_CLKB ODD_CAPTURE_CLK ODD_CAPTURE_CLKB VDD VSS EVEN_Q EVEN_QB ODD_Q
+ ODD_QB
X0 VSS.t11 O_QI.t13 O_QBI.t10 VSS.t10 nfet_03v3 ad=2.08p pd=8.52u as=3.52p ps=16.88u w=8u l=0.28u
X1 VDD.t31 EVEN_DB.t7 EVEN_D_BUF.t4 VDD.t30 pfet_03v3 ad=2.08p pd=8.52u as=2.08p ps=8.52u w=8u l=0.28u
X2 VSS.t60 E_QI.t13 E_QBI.t2 VSS.t59 nfet_03v3 ad=2.08p pd=8.52u as=3.52p ps=16.88u w=8u l=0.28u
X3 ODD_DB_BUF.t1 ODD_D.t10 VDD.t67 VDD.t66 pfet_03v3 ad=2.08p pd=8.52u as=2.08p ps=8.52u w=8u l=0.28u
X4 VSS.t74 E_QBBUF.t6 EVEN_Q.t1 VSS.t73 nfet_03v3 ad=2.08p pd=8.52u as=3.52p ps=16.88u w=8u l=0.28u
X5 VDD.t141 EVEN_CAPTURE_CLKB.t13 E_PRST_TAIL.t4 VDD.t140 pfet_03v3 ad=2.08p pd=8.52u as=2.08p ps=8.52u w=8u l=0.28u
X6 VDD.t44 ODD_CAPTURE_CLKB.t9 O_PRST_TAIL.t10 VDD.t43 pfet_03v3 ad=2.08p pd=8.52u as=2.08p ps=8.52u w=8u l=0.28u
X7 VDD.t156 EVEN_CAPTURE_CLKB.t1 E_PSET_TAIL.t10 VDD.t147 pfet_03v3 ad=2.08p pd=8.52u as=2.08p ps=8.52u w=8u l=0.28u
X8 VDD.t123 O_QBI.t17 O_QI.t10 VDD.t4 pfet_03v3 ad=2.08p pd=8.52u as=3.52p ps=16.88u w=8u l=0.28u
X9 O_QBI.t11 O_QI.t12 VSS.t9 VSS.t8 nfet_03v3 ad=3.52p pd=16.88u as=2.08p ps=8.52u w=8u l=0.28u
X10 VDD.t69 ODD_D.t11 ODD_DB_BUF.t0 VDD.t68 pfet_03v3 ad=2.08p pd=8.52u as=3.52p ps=16.88u w=8u l=0.28u
X11 E_RST_TAIL.t7 EVEN_CAPTURE_CLK.t4 VSS.t131 VSS.t59 nfet_03v3 ad=2.08p pd=8.52u as=2.08p ps=8.52u w=8u l=0.28u
X12 EVEN_Q.t2 E_QBBUF.t5 VSS.t76 VSS.t75 nfet_03v3 ad=2.08p pd=8.52u as=2.08p ps=8.52u w=8u l=0.28u
X13 O_RST_TAIL.t9 ODD_CAPTURE_CLK.t2 VSS.t109 VSS.t16 nfet_03v3 ad=2.08p pd=8.52u as=2.08p ps=8.52u w=8u l=0.28u
X14 VDD.t113 O_QBBUF.t10 ODD_Q.t2 VDD.t112 pfet_03v3 ad=2.08p pd=8.52u as=3.52p ps=16.88u w=8u l=0.28u
X15 O_PSET_TAIL.t4 ODD_CAPTURE_CLKB.t6 VDD.t56 VDD.t40 pfet_03v3 ad=2.08p pd=8.52u as=2.08p ps=8.52u w=8u l=0.28u
X16 O_QI.t6 ODD_DB_BUF.t14 O_RST_TAIL.t3 VSS.t26 nfet_03v3 ad=2.08p pd=8.52u as=2.08p ps=8.52u w=8u l=0.28u
X17 E_QI.t11 EVEN_DB_BUF.t12 E_RST_TAIL.t2 VSS.t17 nfet_03v3 ad=3.52p pd=16.88u as=2.08p ps=8.52u w=8u l=0.28u
X18 ODD_Q.t6 O_QBBUF.t7 VDD.t163 VDD.t162 pfet_03v3 ad=3.52p pd=16.88u as=2.08p ps=8.52u w=8u l=0.28u
X19 VDD.t47 ODD_CAPTURE_CLKB.t7 O_PSET_TAIL.t3 VDD.t46 pfet_03v3 ad=2.08p pd=8.52u as=3.52p ps=16.88u w=8u l=0.28u
X20 E_RST_TAIL.t3 EVEN_DB_BUF.t15 E_QI.t8 VSS.t80 nfet_03v3 ad=2.08p pd=8.52u as=3.52p ps=16.88u w=8u l=0.28u
X21 E_PRST_TAIL.t7 EVEN_CAPTURE_CLKB.t10 VDD.t146 VDD.t145 pfet_03v3 ad=2.08p pd=8.52u as=2.08p ps=8.52u w=8u l=0.28u
X22 EVEN_DB_BUF.t5 EVEN_D.t6 VDD.t93 VDD.t92 pfet_03v3 ad=2.08p pd=8.52u as=2.08p ps=8.52u w=8u l=0.28u
X23 VSS.t114 EVEN_CAPTURE_CLK.t11 E_SET_TAIL.t8 VSS.t0 nfet_03v3 ad=2.08p pd=8.52u as=2.08p ps=8.52u w=8u l=0.28u
X24 O_PRST_TAIL.t7 ODD_CAPTURE_CLKB.t12 VDD.t45 VDD.t2 pfet_03v3 ad=2.08p pd=8.52u as=2.08p ps=8.52u w=8u l=0.28u
X25 VSS.t100 ODD_CAPTURE_CLK.t11 O_SET_TAIL.t8 VSS.t25 nfet_03v3 ad=2.08p pd=8.52u as=2.08p ps=8.52u w=8u l=0.28u
X26 ODD_DB_BUF.t7 ODD_D.t4 VDD.t77 VDD.t76 pfet_03v3 ad=3.52p pd=16.88u as=2.08p ps=8.52u w=8u l=0.28u
X27 O_PRST_TAIL.t1 ODD_D_BUF.t19 O_QBI.t1 VDD.t5 pfet_03v3 ad=2.08p pd=8.52u as=3.52p ps=16.88u w=8u l=0.28u
X28 VSS.t107 ODD_CAPTURE_CLK.t5 O_RST_TAIL.t6 VSS.t14 nfet_03v3 ad=2.08p pd=8.52u as=2.08p ps=8.52u w=8u l=0.28u
X29 VSS.t134 EVEN_CAPTURE_CLK.t1 E_RST_TAIL.t10 VSS.t133 nfet_03v3 ad=2.08p pd=8.52u as=2.08p ps=8.52u w=8u l=0.28u
X30 E_SET_TAIL.t5 EVEN_CAPTURE_CLK.t14 VSS.t119 VSS.t118 nfet_03v3 ad=2.08p pd=8.52u as=2.08p ps=8.52u w=8u l=0.28u
X31 VDD.t129 E_QBI.t19 E_QBUF.t3 VDD.t128 pfet_03v3 ad=2.08p pd=8.52u as=3.52p ps=16.88u w=8u l=0.28u
X32 VDD.t83 EVEN_D.t5 EVEN_DB_BUF.t6 VDD.t82 pfet_03v3 ad=2.08p pd=8.52u as=2.08p ps=8.52u w=8u l=0.28u
X33 O_SET_TAIL.t11 ODD_CAPTURE_CLK.t8 VSS.t93 VSS.t92 nfet_03v3 ad=3.52p pd=16.88u as=2.08p ps=8.52u w=8u l=0.28u
X34 E_QI.t0 E_QBI.t12 VSS.t12 VSS.t0 nfet_03v3 ad=3.52p pd=16.88u as=2.08p ps=8.52u w=8u l=0.28u
X35 EVEN_D_BUF.t11 EVEN_DB.t0 VSS.t34 VSS.t33 nfet_03v3 ad=3.52p pd=16.88u as=2.08p ps=8.52u w=8u l=0.28u
X36 E_QBI.t6 EVEN_D_BUF.t18 E_PRST_TAIL.t0 VDD.t15 pfet_03v3 ad=2.08p pd=8.52u as=2.08p ps=8.52u w=8u l=0.28u
X37 O_QBI.t6 ODD_D_BUF.t16 O_PRST_TAIL.t2 VDD.t17 pfet_03v3 ad=3.52p pd=16.88u as=2.08p ps=8.52u w=8u l=0.28u
X38 O_PSET_TAIL.t10 ODD_CAPTURE_CLKB.t0 VDD.t61 VDD.t54 pfet_03v3 ad=3.52p pd=16.88u as=2.08p ps=8.52u w=8u l=0.28u
X39 VDD.t134 E_QBUF.t8 EVEN_QB.t6 VDD.t133 pfet_03v3 ad=2.08p pd=8.52u as=2.08p ps=8.52u w=8u l=0.28u
X40 VDD.t159 O_QBUF.t8 ODD_QB.t6 VDD.t158 pfet_03v3 ad=2.08p pd=8.52u as=2.08p ps=8.52u w=8u l=0.28u
X41 E_QI.t7 EVEN_DB_BUF.t16 E_PSET_TAIL.t3 VDD.t130 pfet_03v3 ad=3.52p pd=16.88u as=2.08p ps=8.52u w=8u l=0.28u
X42 O_QBUF.t0 O_QBI.t18 VDD.t115 VDD.t114 pfet_03v3 ad=3.52p pd=16.88u as=2.08p ps=8.52u w=8u l=0.28u
X43 VSS.t65 O_QBI.t13 O_QI.t8 VSS.t26 nfet_03v3 ad=2.08p pd=8.52u as=3.52p ps=16.88u w=8u l=0.28u
X44 O_SET_TAIL.t5 ODD_CAPTURE_CLK.t14 VSS.t97 VSS.t96 nfet_03v3 ad=2.08p pd=8.52u as=2.08p ps=8.52u w=8u l=0.28u
X45 E_SET_TAIL.t11 EVEN_CAPTURE_CLK.t8 VSS.t126 VSS.t125 nfet_03v3 ad=3.52p pd=16.88u as=2.08p ps=8.52u w=8u l=0.28u
X46 E_QBUF.t0 E_QBI.t14 VSS.t5 VSS.t4 nfet_03v3 ad=1.76p pd=8.88u as=1.04p ps=4.52u w=4u l=0.28u
X47 VSS.t36 ODD_D.t3 ODD_DB_BUF.t8 VSS.t35 nfet_03v3 ad=2.08p pd=8.52u as=3.52p ps=16.88u w=8u l=0.28u
X48 VSS.t89 O_QBI.t15 O_QBUF.t3 VSS.t88 nfet_03v3 ad=1.04p pd=4.52u as=1.76p ps=8.88u w=4u l=0.28u
X49 O_QBBUF.t3 O_QI.t14 VSS.t66 VSS.t51 nfet_03v3 ad=1.76p pd=8.88u as=1.04p ps=4.52u w=4u l=0.28u
X50 VSS.t46 EVEN_D.t1 EVEN_DB_BUF.t10 VSS.t45 nfet_03v3 ad=2.08p pd=8.52u as=2.08p ps=8.52u w=8u l=0.28u
X51 VDD.t107 ODD_DB.t5 ODD_D_BUF.t6 VDD.t106 pfet_03v3 ad=2.08p pd=8.52u as=2.08p ps=8.52u w=8u l=0.28u
X52 VDD.t137 EVEN_CAPTURE_CLKB.t15 E_PRST_TAIL.t2 VDD.t135 pfet_03v3 ad=2.08p pd=8.52u as=3.52p ps=16.88u w=8u l=0.28u
X53 VSS.t108 ODD_CAPTURE_CLK.t3 O_RST_TAIL.t8 VSS.t8 nfet_03v3 ad=2.08p pd=8.52u as=2.08p ps=8.52u w=8u l=0.28u
X54 EVEN_D_BUF.t7 EVEN_DB.t4 VDD.t39 VDD.t38 pfet_03v3 ad=3.52p pd=16.88u as=2.08p ps=8.52u w=8u l=0.28u
X55 E_RST_TAIL.t5 EVEN_CAPTURE_CLK.t6 VSS.t130 VSS.t129 nfet_03v3 ad=2.08p pd=8.52u as=2.08p ps=8.52u w=8u l=0.28u
X56 ODD_D_BUF.t5 ODD_DB.t6 VDD.t105 VDD.t104 pfet_03v3 ad=2.08p pd=8.52u as=2.08p ps=8.52u w=8u l=0.28u
X57 VDD.t8 E_QBUF.t10 EVEN_QB.t0 VDD.t7 pfet_03v3 ad=2.08p pd=8.52u as=3.52p ps=16.88u w=8u l=0.28u
X58 O_RST_TAIL.t11 ODD_CAPTURE_CLK.t0 VSS.t113 VSS.t112 nfet_03v3 ad=3.52p pd=16.88u as=2.08p ps=8.52u w=8u l=0.28u
X59 EVEN_Q.t6 E_QBBUF.t9 VDD.t169 VDD.t168 pfet_03v3 ad=2.08p pd=8.52u as=2.08p ps=8.52u w=8u l=0.28u
X60 VDD.t19 O_QBBUF.t8 ODD_Q.t1 VDD.t18 pfet_03v3 ad=2.08p pd=8.52u as=2.08p ps=8.52u w=8u l=0.28u
X61 O_QBI.t4 ODD_D_BUF.t12 O_SET_TAIL.t2 VSS.t16 nfet_03v3 ad=3.52p pd=16.88u as=2.08p ps=8.52u w=8u l=0.28u
X62 E_QBI.t4 EVEN_D_BUF.t14 E_SET_TAIL.t0 VSS.t59 nfet_03v3 ad=2.08p pd=8.52u as=2.08p ps=8.52u w=8u l=0.28u
X63 ODD_D_BUF.t11 ODD_DB.t0 VSS.t58 VSS.t57 nfet_03v3 ad=3.52p pd=16.88u as=2.08p ps=8.52u w=8u l=0.28u
X64 E_PSET_TAIL.t11 EVEN_CAPTURE_CLKB.t0 VDD.t157 VDD.t149 pfet_03v3 ad=3.52p pd=16.88u as=2.08p ps=8.52u w=8u l=0.28u
X65 E_SET_TAIL.t9 EVEN_CAPTURE_CLK.t10 VSS.t121 VSS.t17 nfet_03v3 ad=2.08p pd=8.52u as=2.08p ps=8.52u w=8u l=0.28u
X66 O_SET_TAIL.t7 ODD_CAPTURE_CLK.t12 VSS.t99 VSS.t26 nfet_03v3 ad=2.08p pd=8.52u as=2.08p ps=8.52u w=8u l=0.28u
X67 VSS.t32 EVEN_DB.t1 EVEN_D_BUF.t10 VSS.t31 nfet_03v3 ad=2.08p pd=8.52u as=2.08p ps=8.52u w=8u l=0.28u
X68 VSS.t83 O_QBUF.t4 ODD_QB.t5 VSS.t82 nfet_03v3 ad=3.52p pd=16.88u as=2.08p ps=8.52u w=8u l=0.28u
X69 O_QI.t4 ODD_DB_BUF.t16 O_PSET_TAIL.t2 VDD.t17 pfet_03v3 ad=3.52p pd=16.88u as=2.08p ps=8.52u w=8u l=0.28u
X70 VSS.t85 E_QBBUF.t4 EVEN_Q.t3 VSS.t84 nfet_03v3 ad=3.52p pd=16.88u as=2.08p ps=8.52u w=8u l=0.28u
X71 VDD.t25 EVEN_DB.t11 EVEN_D_BUF.t0 VDD.t24 pfet_03v3 ad=2.08p pd=8.52u as=3.52p ps=16.88u w=8u l=0.28u
X72 O_RST_TAIL.t5 ODD_CAPTURE_CLK.t6 VSS.t106 VSS.t105 nfet_03v3 ad=2.08p pd=8.52u as=2.08p ps=8.52u w=8u l=0.28u
X73 E_RST_TAIL.t11 EVEN_CAPTURE_CLK.t0 VSS.t137 VSS.t136 nfet_03v3 ad=3.52p pd=16.88u as=2.08p ps=8.52u w=8u l=0.28u
X74 VSS.t120 EVEN_CAPTURE_CLK.t13 E_SET_TAIL.t6 VSS.t80 nfet_03v3 ad=2.08p pd=8.52u as=2.08p ps=8.52u w=8u l=0.28u
X75 VSS.t103 ODD_CAPTURE_CLK.t9 O_SET_TAIL.t10 VSS.t102 nfet_03v3 ad=2.08p pd=8.52u as=2.08p ps=8.52u w=8u l=0.28u
X76 E_PRST_TAIL.t11 EVEN_D_BUF.t17 E_QBI.t11 VDD.t13 pfet_03v3 ad=2.08p pd=8.52u as=2.08p ps=8.52u w=8u l=0.28u
X77 VSS.t68 E_QI.t15 E_QBBUF.t2 VSS.t29 nfet_03v3 ad=1.04p pd=4.52u as=1.76p ps=8.88u w=4u l=0.28u
X78 O_PRST_TAIL.t3 ODD_D_BUF.t17 O_QBI.t7 VDD.t6 pfet_03v3 ad=2.08p pd=8.52u as=2.08p ps=8.52u w=8u l=0.28u
X79 EVEN_QB.t4 E_QBUF.t7 VDD.t125 VDD.t124 pfet_03v3 ad=3.52p pd=16.88u as=2.08p ps=8.52u w=8u l=0.28u
X80 VSS.t132 EVEN_CAPTURE_CLK.t3 E_RST_TAIL.t8 VSS.t79 nfet_03v3 ad=2.08p pd=8.52u as=2.08p ps=8.52u w=8u l=0.28u
X81 ODD_QB.t3 O_QBUF.t9 VDD.t79 VDD.t78 pfet_03v3 ad=2.08p pd=8.52u as=2.08p ps=8.52u w=8u l=0.28u
X82 VDD.t136 EVEN_CAPTURE_CLKB.t7 E_PSET_TAIL.t4 VDD.t135 pfet_03v3 ad=2.08p pd=8.52u as=3.52p ps=16.88u w=8u l=0.28u
X83 EVEN_D_BUF.t1 EVEN_DB.t10 VDD.t27 VDD.t26 pfet_03v3 ad=2.08p pd=8.52u as=2.08p ps=8.52u w=8u l=0.28u
X84 VDD.t73 ODD_D.t7 ODD_DB_BUF.t4 VDD.t72 pfet_03v3 ad=2.08p pd=8.52u as=2.08p ps=8.52u w=8u l=0.28u
X85 O_SET_TAIL.t1 ODD_D_BUF.t15 O_QBI.t3 VSS.t14 nfet_03v3 ad=2.08p pd=8.52u as=3.52p ps=16.88u w=8u l=0.28u
X86 ODD_DB_BUF.t9 ODD_D.t2 VSS.t38 VSS.t37 nfet_03v3 ad=2.08p pd=8.52u as=2.08p ps=8.52u w=8u l=0.28u
X87 VDD.t71 ODD_D.t5 ODD_DB_BUF.t6 VDD.t70 pfet_03v3 ad=2.08p pd=8.52u as=2.08p ps=8.52u w=8u l=0.28u
X88 VDD.t48 ODD_CAPTURE_CLKB.t15 O_PRST_TAIL.t4 VDD.t46 pfet_03v3 ad=2.08p pd=8.52u as=3.52p ps=16.88u w=8u l=0.28u
X89 E_PSET_TAIL.t5 EVEN_CAPTURE_CLKB.t6 VDD.t151 VDD.t138 pfet_03v3 ad=2.08p pd=8.52u as=2.08p ps=8.52u w=8u l=0.28u
X90 E_QBUF.t2 E_QBI.t18 VDD.t127 VDD.t126 pfet_03v3 ad=3.52p pd=16.88u as=2.08p ps=8.52u w=8u l=0.28u
X91 EVEN_DB_BUF.t7 EVEN_D.t4 VDD.t95 VDD.t94 pfet_03v3 ad=3.52p pd=16.88u as=2.08p ps=8.52u w=8u l=0.28u
X92 ODD_DB_BUF.t5 ODD_D.t6 VDD.t75 VDD.t74 pfet_03v3 ad=2.08p pd=8.52u as=2.08p ps=8.52u w=8u l=0.28u
X93 VDD.t60 ODD_CAPTURE_CLKB.t1 O_PSET_TAIL.t9 VDD.t43 pfet_03v3 ad=2.08p pd=8.52u as=2.08p ps=8.52u w=8u l=0.28u
X94 ODD_D_BUF.t9 ODD_DB.t2 VSS.t56 VSS.t55 nfet_03v3 ad=2.08p pd=8.52u as=2.08p ps=8.52u w=8u l=0.28u
X95 VDD.t117 O_QBI.t19 O_QBUF.t1 VDD.t116 pfet_03v3 ad=2.08p pd=8.52u as=3.52p ps=16.88u w=8u l=0.28u
X96 O_QBBUF.t1 O_QI.t18 VDD.t10 VDD.t9 pfet_03v3 ad=3.52p pd=16.88u as=2.08p ps=8.52u w=8u l=0.28u
X97 O_PSET_TAIL.t8 ODD_CAPTURE_CLKB.t2 VDD.t59 VDD.t52 pfet_03v3 ad=2.08p pd=8.52u as=2.08p ps=8.52u w=8u l=0.28u
X98 VDD.t85 EVEN_D.t11 EVEN_DB_BUF.t0 VDD.t84 pfet_03v3 ad=2.08p pd=8.52u as=3.52p ps=16.88u w=8u l=0.28u
X99 VSS.t111 ODD_CAPTURE_CLK.t1 O_RST_TAIL.t10 VSS.t110 nfet_03v3 ad=2.08p pd=8.52u as=2.08p ps=8.52u w=8u l=0.28u
X100 VSS.t122 EVEN_CAPTURE_CLK.t5 E_RST_TAIL.t6 VSS.t77 nfet_03v3 ad=2.08p pd=8.52u as=2.08p ps=8.52u w=8u l=0.28u
X101 VDD.t119 E_QBBUF.t8 EVEN_Q.t0 VDD.t118 pfet_03v3 ad=2.08p pd=8.52u as=2.08p ps=8.52u w=8u l=0.28u
X102 ODD_Q.t4 O_QBBUF.t9 VDD.t161 VDD.t160 pfet_03v3 ad=2.08p pd=8.52u as=2.08p ps=8.52u w=8u l=0.28u
X103 O_SET_TAIL.t3 ODD_D_BUF.t13 O_QBI.t5 VSS.t8 nfet_03v3 ad=2.08p pd=8.52u as=2.08p ps=8.52u w=8u l=0.28u
X104 EVEN_DB_BUF.t3 EVEN_D.t8 VDD.t91 VDD.t90 pfet_03v3 ad=2.08p pd=8.52u as=2.08p ps=8.52u w=8u l=0.28u
X105 VSS.t67 O_QI.t15 O_QBBUF.t2 VSS.t55 nfet_03v3 ad=1.04p pd=4.52u as=1.76p ps=8.88u w=4u l=0.28u
X106 EVEN_DB_BUF.t1 EVEN_D.t10 VDD.t81 VDD.t80 pfet_03v3 ad=2.08p pd=8.52u as=2.08p ps=8.52u w=8u l=0.28u
X107 VSS.t54 ODD_DB.t3 ODD_D_BUF.t8 VSS.t53 nfet_03v3 ad=2.08p pd=8.52u as=3.52p ps=16.88u w=8u l=0.28u
X108 VSS.t72 E_QBUF.t6 EVEN_QB.t3 VSS.t71 nfet_03v3 ad=2.08p pd=8.52u as=3.52p ps=16.88u w=8u l=0.28u
X109 E_PSET_TAIL.t0 EVEN_DB_BUF.t19 E_QI.t4 VDD.t110 pfet_03v3 ad=2.08p pd=8.52u as=3.52p ps=16.88u w=8u l=0.28u
X110 VDD.t102 ODD_DB.t9 ODD_D_BUF.t2 VDD.t101 pfet_03v3 ad=2.08p pd=8.52u as=2.08p ps=8.52u w=8u l=0.28u
X111 E_PRST_TAIL.t5 EVEN_CAPTURE_CLKB.t12 VDD.t143 VDD.t142 pfet_03v3 ad=2.08p pd=8.52u as=2.08p ps=8.52u w=8u l=0.28u
X112 O_PRST_TAIL.t9 ODD_CAPTURE_CLKB.t10 VDD.t53 VDD.t52 pfet_03v3 ad=2.08p pd=8.52u as=2.08p ps=8.52u w=8u l=0.28u
X113 E_QBI.t10 EVEN_D_BUF.t16 E_PRST_TAIL.t10 VDD.t130 pfet_03v3 ad=3.52p pd=16.88u as=2.08p ps=8.52u w=8u l=0.28u
X114 E_RST_TAIL.t9 EVEN_CAPTURE_CLK.t2 VSS.t135 VSS.t78 nfet_03v3 ad=2.08p pd=8.52u as=2.08p ps=8.52u w=8u l=0.28u
X115 EVEN_QB.t1 E_QBUF.t5 VSS.t22 VSS.t21 nfet_03v3 ad=2.08p pd=8.52u as=2.08p ps=8.52u w=8u l=0.28u
X116 VDD.t103 ODD_DB.t7 ODD_D_BUF.t4 VDD.t9 pfet_03v3 ad=2.08p pd=8.52u as=2.08p ps=8.52u w=8u l=0.28u
X117 O_QBI.t0 ODD_D_BUF.t18 O_PRST_TAIL.t0 VDD.t4 pfet_03v3 ad=2.08p pd=8.52u as=2.08p ps=8.52u w=8u l=0.28u
X118 O_RST_TAIL.t7 ODD_CAPTURE_CLK.t4 VSS.t104 VSS.t10 nfet_03v3 ad=2.08p pd=8.52u as=2.08p ps=8.52u w=8u l=0.28u
X119 VSS.t116 EVEN_CAPTURE_CLK.t15 E_SET_TAIL.t4 VSS.t115 nfet_03v3 ad=2.08p pd=8.52u as=3.52p ps=16.88u w=8u l=0.28u
X120 E_QI.t5 EVEN_DB_BUF.t18 E_PSET_TAIL.t2 VDD.t15 pfet_03v3 ad=2.08p pd=8.52u as=2.08p ps=8.52u w=8u l=0.28u
X121 VSS.t48 EVEN_D.t3 EVEN_DB_BUF.t8 VSS.t47 nfet_03v3 ad=2.08p pd=8.52u as=3.52p ps=16.88u w=8u l=0.28u
X122 VDD.t111 E_QI.t19 E_QBBUF.t0 VDD.t32 pfet_03v3 ad=2.08p pd=8.52u as=3.52p ps=16.88u w=8u l=0.28u
X123 E_PRST_TAIL.t1 EVEN_D_BUF.t19 E_QBI.t7 VDD.t110 pfet_03v3 ad=2.08p pd=8.52u as=3.52p ps=16.88u w=8u l=0.28u
X124 O_RST_TAIL.t1 ODD_DB_BUF.t15 O_QI.t3 VSS.t20 nfet_03v3 ad=2.08p pd=8.52u as=3.52p ps=16.88u w=8u l=0.28u
X125 ODD_QB.t0 O_QBUF.t5 VSS.t3 VSS.t2 nfet_03v3 ad=2.08p pd=8.52u as=2.08p ps=8.52u w=8u l=0.28u
X126 O_PSET_TAIL.t0 ODD_DB_BUF.t17 O_QI.t0 VDD.t6 pfet_03v3 ad=2.08p pd=8.52u as=2.08p ps=8.52u w=8u l=0.28u
X127 E_SET_TAIL.t3 EVEN_D_BUF.t13 E_QBI.t9 VSS.t79 nfet_03v3 ad=2.08p pd=8.52u as=2.08p ps=8.52u w=8u l=0.28u
X128 VSS.t19 O_QBBUF.t4 ODD_Q.t0 VSS.t18 nfet_03v3 ad=3.52p pd=16.88u as=2.08p ps=8.52u w=8u l=0.28u
X129 O_QI.t2 ODD_DB_BUF.t12 O_RST_TAIL.t0 VSS.t15 nfet_03v3 ad=3.52p pd=16.88u as=2.08p ps=8.52u w=8u l=0.28u
X130 E_QI.t9 EVEN_DB_BUF.t14 E_RST_TAIL.t1 VSS.t1 nfet_03v3 ad=2.08p pd=8.52u as=2.08p ps=8.52u w=8u l=0.28u
X131 VDD.t148 EVEN_CAPTURE_CLKB.t9 E_PRST_TAIL.t8 VDD.t147 pfet_03v3 ad=2.08p pd=8.52u as=2.08p ps=8.52u w=8u l=0.28u
X132 VDD.t50 ODD_CAPTURE_CLKB.t13 O_PRST_TAIL.t6 VDD.t49 pfet_03v3 ad=2.08p pd=8.52u as=2.08p ps=8.52u w=8u l=0.28u
X133 VSS.t63 O_QBUF.t6 ODD_QB.t4 VSS.t62 nfet_03v3 ad=2.08p pd=8.52u as=3.52p ps=16.88u w=8u l=0.28u
X134 E_QBBUF.t3 E_QI.t14 VSS.t61 VSS.t31 nfet_03v3 ad=1.76p pd=8.88u as=1.04p ps=4.52u w=4u l=0.28u
X135 VDD.t29 EVEN_DB.t9 EVEN_D_BUF.t2 VDD.t28 pfet_03v3 ad=2.08p pd=8.52u as=2.08p ps=8.52u w=8u l=0.28u
X136 ODD_DB_BUF.t3 ODD_D.t8 VDD.t63 VDD.t62 pfet_03v3 ad=2.08p pd=8.52u as=2.08p ps=8.52u w=8u l=0.28u
X137 EVEN_DB_BUF.t9 EVEN_D.t2 VSS.t50 VSS.t49 nfet_03v3 ad=2.08p pd=8.52u as=2.08p ps=8.52u w=8u l=0.28u
X138 VDD.t154 EVEN_CAPTURE_CLKB.t3 E_PSET_TAIL.t8 VDD.t120 pfet_03v3 ad=2.08p pd=8.52u as=2.08p ps=8.52u w=8u l=0.28u
X139 VDD.t16 E_QBI.t17 E_QI.t3 VDD.t15 pfet_03v3 ad=2.08p pd=8.52u as=3.52p ps=16.88u w=8u l=0.28u
X140 VDD.t152 EVEN_CAPTURE_CLKB.t5 E_PSET_TAIL.t6 VDD.t140 pfet_03v3 ad=2.08p pd=8.52u as=2.08p ps=8.52u w=8u l=0.28u
X141 EVEN_D_BUF.t3 EVEN_DB.t8 VDD.t33 VDD.t32 pfet_03v3 ad=2.08p pd=8.52u as=2.08p ps=8.52u w=8u l=0.28u
X142 VDD.t65 ODD_D.t9 ODD_DB_BUF.t2 VDD.t64 pfet_03v3 ad=2.08p pd=8.52u as=2.08p ps=8.52u w=8u l=0.28u
X143 EVEN_Q.t5 E_QBBUF.t7 VDD.t167 VDD.t166 pfet_03v3 ad=3.52p pd=16.88u as=2.08p ps=8.52u w=8u l=0.28u
X144 O_PSET_TAIL.t6 ODD_CAPTURE_CLKB.t4 VDD.t42 VDD.t2 pfet_03v3 ad=2.08p pd=8.52u as=2.08p ps=8.52u w=8u l=0.28u
X145 O_QI.t9 O_QBI.t16 VDD.t122 VDD.t6 pfet_03v3 ad=3.52p pd=16.88u as=2.08p ps=8.52u w=8u l=0.28u
X146 E_PSET_TAIL.t7 EVEN_CAPTURE_CLKB.t4 VDD.t153 VDD.t142 pfet_03v3 ad=2.08p pd=8.52u as=2.08p ps=8.52u w=8u l=0.28u
X147 VSS.t128 EVEN_CAPTURE_CLK.t7 E_RST_TAIL.t4 VSS.t127 nfet_03v3 ad=2.08p pd=8.52u as=3.52p ps=16.88u w=8u l=0.28u
X148 VSS.t95 ODD_CAPTURE_CLK.t15 O_SET_TAIL.t4 VSS.t94 nfet_03v3 ad=2.08p pd=8.52u as=3.52p ps=16.88u w=8u l=0.28u
X149 EVEN_D_BUF.t9 EVEN_DB.t2 VSS.t30 VSS.t29 nfet_03v3 ad=2.08p pd=8.52u as=2.08p ps=8.52u w=8u l=0.28u
X150 VDD.t165 E_QBBUF.t10 EVEN_Q.t4 VDD.t164 pfet_03v3 ad=2.08p pd=8.52u as=3.52p ps=16.88u w=8u l=0.28u
X151 VDD.t12 O_QI.t19 O_QBBUF.t0 VDD.t11 pfet_03v3 ad=2.08p pd=8.52u as=3.52p ps=16.88u w=8u l=0.28u
X152 E_SET_TAIL.t1 EVEN_D_BUF.t15 E_QBI.t5 VSS.t77 nfet_03v3 ad=2.08p pd=8.52u as=3.52p ps=16.88u w=8u l=0.28u
X153 VDD.t57 ODD_CAPTURE_CLKB.t5 O_PSET_TAIL.t5 VDD.t49 pfet_03v3 ad=2.08p pd=8.52u as=2.08p ps=8.52u w=8u l=0.28u
X154 VDD.t51 ODD_CAPTURE_CLKB.t11 O_PRST_TAIL.t8 VDD.t0 pfet_03v3 ad=2.08p pd=8.52u as=2.08p ps=8.52u w=8u l=0.28u
X155 VDD.t58 ODD_CAPTURE_CLKB.t3 O_PSET_TAIL.t7 VDD.t0 pfet_03v3 ad=2.08p pd=8.52u as=2.08p ps=8.52u w=8u l=0.28u
X156 E_QBI.t1 E_QI.t16 VDD.t121 VDD.t120 pfet_03v3 ad=3.52p pd=16.88u as=2.08p ps=8.52u w=8u l=0.28u
X157 E_PRST_TAIL.t3 EVEN_CAPTURE_CLKB.t14 VDD.t139 VDD.t138 pfet_03v3 ad=2.08p pd=8.52u as=2.08p ps=8.52u w=8u l=0.28u
X158 O_PRST_TAIL.t11 ODD_CAPTURE_CLKB.t8 VDD.t55 VDD.t54 pfet_03v3 ad=3.52p pd=16.88u as=2.08p ps=8.52u w=8u l=0.28u
X159 VDD.t89 EVEN_D.t7 EVEN_DB_BUF.t4 VDD.t88 pfet_03v3 ad=2.08p pd=8.52u as=2.08p ps=8.52u w=8u l=0.28u
X160 VSS.t40 ODD_D.t1 ODD_DB_BUF.t10 VSS.t39 nfet_03v3 ad=2.08p pd=8.52u as=2.08p ps=8.52u w=8u l=0.28u
X161 VDD.t87 EVEN_D.t9 EVEN_DB_BUF.t2 VDD.t86 pfet_03v3 ad=2.08p pd=8.52u as=2.08p ps=8.52u w=8u l=0.28u
X162 EVEN_DB_BUF.t11 EVEN_D.t0 VSS.t44 VSS.t43 nfet_03v3 ad=3.52p pd=16.88u as=2.08p ps=8.52u w=8u l=0.28u
X163 VDD.t3 O_QI.t17 O_QBI.t8 VDD.t2 pfet_03v3 ad=2.08p pd=8.52u as=3.52p ps=16.88u w=8u l=0.28u
X164 E_QBI.t8 EVEN_D_BUF.t12 E_SET_TAIL.t2 VSS.t78 nfet_03v3 ad=3.52p pd=16.88u as=2.08p ps=8.52u w=8u l=0.28u
X165 O_QBI.t2 ODD_D_BUF.t14 O_SET_TAIL.t0 VSS.t10 nfet_03v3 ad=2.08p pd=8.52u as=2.08p ps=8.52u w=8u l=0.28u
X166 ODD_QB.t2 O_QBUF.t7 VDD.t23 VDD.t22 pfet_03v3 ad=3.52p pd=16.88u as=2.08p ps=8.52u w=8u l=0.28u
X167 VDD.t170 E_QI.t17 E_QBI.t0 VDD.t142 pfet_03v3 ad=2.08p pd=8.52u as=3.52p ps=16.88u w=8u l=0.28u
X168 ODD_D_BUF.t1 ODD_DB.t10 VDD.t99 VDD.t98 pfet_03v3 ad=2.08p pd=8.52u as=2.08p ps=8.52u w=8u l=0.28u
X169 O_RST_TAIL.t2 ODD_DB_BUF.t13 O_QI.t5 VSS.t25 nfet_03v3 ad=2.08p pd=8.52u as=2.08p ps=8.52u w=8u l=0.28u
X170 E_RST_TAIL.t0 EVEN_DB_BUF.t13 E_QI.t10 VSS.t0 nfet_03v3 ad=2.08p pd=8.52u as=2.08p ps=8.52u w=8u l=0.28u
X171 VSS.t13 E_QBI.t13 E_QI.t1 VSS.t1 nfet_03v3 ad=2.08p pd=8.52u as=3.52p ps=16.88u w=8u l=0.28u
X172 E_PRST_TAIL.t9 EVEN_CAPTURE_CLKB.t8 VDD.t150 VDD.t149 pfet_03v3 ad=3.52p pd=16.88u as=2.08p ps=8.52u w=8u l=0.28u
X173 O_PRST_TAIL.t5 ODD_CAPTURE_CLKB.t14 VDD.t41 VDD.t40 pfet_03v3 ad=2.08p pd=8.52u as=2.08p ps=8.52u w=8u l=0.28u
X174 ODD_D_BUF.t3 ODD_DB.t8 VDD.t100 VDD.t11 pfet_03v3 ad=2.08p pd=8.52u as=2.08p ps=8.52u w=8u l=0.28u
X175 VSS.t98 ODD_CAPTURE_CLK.t13 O_SET_TAIL.t6 VSS.t20 nfet_03v3 ad=2.08p pd=8.52u as=2.08p ps=8.52u w=8u l=0.28u
X176 VSS.t124 EVEN_CAPTURE_CLK.t9 E_SET_TAIL.t10 VSS.t123 nfet_03v3 ad=2.08p pd=8.52u as=2.08p ps=8.52u w=8u l=0.28u
X177 VSS.t24 E_QBUF.t4 EVEN_QB.t2 VSS.t23 nfet_03v3 ad=3.52p pd=16.88u as=2.08p ps=8.52u w=8u l=0.28u
X178 E_PSET_TAIL.t1 EVEN_DB_BUF.t17 E_QI.t6 VDD.t13 pfet_03v3 ad=2.08p pd=8.52u as=2.08p ps=8.52u w=8u l=0.28u
X179 VSS.t52 ODD_DB.t1 ODD_D_BUF.t10 VSS.t51 nfet_03v3 ad=2.08p pd=8.52u as=2.08p ps=8.52u w=8u l=0.28u
X180 O_QI.t7 O_QBI.t12 VSS.t64 VSS.t25 nfet_03v3 ad=3.52p pd=16.88u as=2.08p ps=8.52u w=8u l=0.28u
X181 VDD.t144 EVEN_CAPTURE_CLKB.t11 E_PRST_TAIL.t6 VDD.t120 pfet_03v3 ad=2.08p pd=8.52u as=2.08p ps=8.52u w=8u l=0.28u
X182 E_QBBUF.t1 E_QI.t18 VDD.t171 VDD.t30 pfet_03v3 ad=3.52p pd=16.88u as=2.08p ps=8.52u w=8u l=0.28u
X183 O_QBI.t9 O_QI.t16 VDD.t1 VDD.t0 pfet_03v3 ad=3.52p pd=16.88u as=2.08p ps=8.52u w=8u l=0.28u
X184 VDD.t97 ODD_DB.t11 ODD_D_BUF.t0 VDD.t96 pfet_03v3 ad=2.08p pd=8.52u as=3.52p ps=16.88u w=8u l=0.28u
X185 VSS.t91 ODD_CAPTURE_CLK.t7 O_RST_TAIL.t4 VSS.t90 nfet_03v3 ad=2.08p pd=8.52u as=3.52p ps=16.88u w=8u l=0.28u
X186 O_SET_TAIL.t9 ODD_CAPTURE_CLK.t10 VSS.t101 VSS.t15 nfet_03v3 ad=2.08p pd=8.52u as=2.08p ps=8.52u w=8u l=0.28u
X187 E_SET_TAIL.t7 EVEN_CAPTURE_CLK.t12 VSS.t117 VSS.t1 nfet_03v3 ad=2.08p pd=8.52u as=2.08p ps=8.52u w=8u l=0.28u
X188 VSS.t28 EVEN_DB.t3 EVEN_D_BUF.t8 VSS.t27 nfet_03v3 ad=2.08p pd=8.52u as=3.52p ps=16.88u w=8u l=0.28u
X189 VSS.t7 E_QBI.t15 E_QBUF.t1 VSS.t6 nfet_03v3 ad=1.04p pd=4.52u as=1.76p ps=8.88u w=4u l=0.28u
X190 O_QI.t1 ODD_DB_BUF.t18 O_PSET_TAIL.t1 VDD.t4 pfet_03v3 ad=2.08p pd=8.52u as=2.08p ps=8.52u w=8u l=0.28u
X191 ODD_Q.t5 O_QBBUF.t5 VSS.t139 VSS.t138 nfet_03v3 ad=2.08p pd=8.52u as=2.08p ps=8.52u w=8u l=0.28u
X192 VDD.t21 O_QBUF.t10 ODD_QB.t1 VDD.t20 pfet_03v3 ad=2.08p pd=8.52u as=3.52p ps=16.88u w=8u l=0.28u
X193 O_QBUF.t2 O_QBI.t14 VSS.t87 VSS.t86 nfet_03v3 ad=1.76p pd=8.88u as=1.04p ps=4.52u w=4u l=0.28u
X194 EVEN_D_BUF.t5 EVEN_DB.t6 VDD.t35 VDD.t34 pfet_03v3 ad=2.08p pd=8.52u as=2.08p ps=8.52u w=8u l=0.28u
X195 O_PSET_TAIL.t11 ODD_DB_BUF.t19 O_QI.t11 VDD.t5 pfet_03v3 ad=2.08p pd=8.52u as=3.52p ps=16.88u w=8u l=0.28u
X196 E_QBI.t3 E_QI.t12 VSS.t81 VSS.t79 nfet_03v3 ad=3.52p pd=16.88u as=2.08p ps=8.52u w=8u l=0.28u
X197 VSS.t70 O_QBBUF.t6 ODD_Q.t3 VSS.t69 nfet_03v3 ad=2.08p pd=8.52u as=3.52p ps=16.88u w=8u l=0.28u
X198 EVEN_QB.t5 E_QBUF.t9 VDD.t132 VDD.t131 pfet_03v3 ad=2.08p pd=8.52u as=2.08p ps=8.52u w=8u l=0.28u
X199 ODD_D_BUF.t7 ODD_DB.t4 VDD.t109 VDD.t108 pfet_03v3 ad=3.52p pd=16.88u as=2.08p ps=8.52u w=8u l=0.28u
X200 E_PSET_TAIL.t9 EVEN_CAPTURE_CLKB.t2 VDD.t155 VDD.t145 pfet_03v3 ad=2.08p pd=8.52u as=2.08p ps=8.52u w=8u l=0.28u
X201 VDD.t37 EVEN_DB.t5 EVEN_D_BUF.t6 VDD.t36 pfet_03v3 ad=2.08p pd=8.52u as=2.08p ps=8.52u w=8u l=0.28u
X202 E_QI.t2 E_QBI.t16 VDD.t14 VDD.t13 pfet_03v3 ad=3.52p pd=16.88u as=2.08p ps=8.52u w=8u l=0.28u
X203 ODD_DB_BUF.t11 ODD_D.t0 VSS.t42 VSS.t41 nfet_03v3 ad=3.52p pd=16.88u as=2.08p ps=8.52u w=8u l=0.28u
R0 ODD_CAPTURE_CLK.n14 ODD_CAPTURE_CLK.t8 113.632
R1 ODD_CAPTURE_CLK.n18 ODD_CAPTURE_CLK.t15 113.632
R2 ODD_CAPTURE_CLK.n5 ODD_CAPTURE_CLK.t7 113.632
R3 ODD_CAPTURE_CLK.n23 ODD_CAPTURE_CLK.t9 109.174
R4 ODD_CAPTURE_CLK.n24 ODD_CAPTURE_CLK.t10 109.174
R5 ODD_CAPTURE_CLK.n22 ODD_CAPTURE_CLK.t11 109.174
R6 ODD_CAPTURE_CLK.n21 ODD_CAPTURE_CLK.t12 109.174
R7 ODD_CAPTURE_CLK.n16 ODD_CAPTURE_CLK.t13 109.174
R8 ODD_CAPTURE_CLK.n17 ODD_CAPTURE_CLK.t14 109.174
R9 ODD_CAPTURE_CLK.n0 ODD_CAPTURE_CLK.t0 109.174
R10 ODD_CAPTURE_CLK.n11 ODD_CAPTURE_CLK.t1 109.174
R11 ODD_CAPTURE_CLK.n6 ODD_CAPTURE_CLK.t6 109.174
R12 ODD_CAPTURE_CLK.n7 ODD_CAPTURE_CLK.t5 109.174
R13 ODD_CAPTURE_CLK.n8 ODD_CAPTURE_CLK.t4 109.174
R14 ODD_CAPTURE_CLK.n9 ODD_CAPTURE_CLK.t3 109.174
R15 ODD_CAPTURE_CLK.n10 ODD_CAPTURE_CLK.t2 109.174
R16 ODD_CAPTURE_CLK.n27 ODD_CAPTURE_CLK.n13 19.4679
R17 ODD_CAPTURE_CLK.n13 ODD_CAPTURE_CLK.n0 18.5636
R18 ODD_CAPTURE_CLK.n25 ODD_CAPTURE_CLK.n24 18.4942
R19 ODD_CAPTURE_CLK.n22 ODD_CAPTURE_CLK.n15 18.4942
R20 ODD_CAPTURE_CLK.n21 ODD_CAPTURE_CLK.n20 18.4942
R21 ODD_CAPTURE_CLK.n19 ODD_CAPTURE_CLK.n16 18.4942
R22 ODD_CAPTURE_CLK.n12 ODD_CAPTURE_CLK.n11 18.4942
R23 ODD_CAPTURE_CLK.n7 ODD_CAPTURE_CLK.n4 18.4942
R24 ODD_CAPTURE_CLK.n8 ODD_CAPTURE_CLK.n3 18.4942
R25 ODD_CAPTURE_CLK.n9 ODD_CAPTURE_CLK.n2 18.4942
R26 ODD_CAPTURE_CLK.n10 ODD_CAPTURE_CLK.n1 18.4942
R27 ODD_CAPTURE_CLK.n27 ODD_CAPTURE_CLK.n26 14.9288
R28 ODD_CAPTURE_CLK ODD_CAPTURE_CLK.n27 13.2075
R29 ODD_CAPTURE_CLK.n24 ODD_CAPTURE_CLK.n23 11.6805
R30 ODD_CAPTURE_CLK.n24 ODD_CAPTURE_CLK.n22 11.6805
R31 ODD_CAPTURE_CLK.n22 ODD_CAPTURE_CLK.n21 11.6805
R32 ODD_CAPTURE_CLK.n21 ODD_CAPTURE_CLK.n16 11.6805
R33 ODD_CAPTURE_CLK.n17 ODD_CAPTURE_CLK.n16 11.6805
R34 ODD_CAPTURE_CLK.n11 ODD_CAPTURE_CLK.n0 11.6805
R35 ODD_CAPTURE_CLK.n7 ODD_CAPTURE_CLK.n6 11.6805
R36 ODD_CAPTURE_CLK.n8 ODD_CAPTURE_CLK.n7 11.6805
R37 ODD_CAPTURE_CLK.n9 ODD_CAPTURE_CLK.n8 11.6805
R38 ODD_CAPTURE_CLK.n10 ODD_CAPTURE_CLK.n9 11.6805
R39 ODD_CAPTURE_CLK.n11 ODD_CAPTURE_CLK.n10 11.6805
R40 ODD_CAPTURE_CLK.n19 ODD_CAPTURE_CLK.n18 7.17687
R41 ODD_CAPTURE_CLK.n5 ODD_CAPTURE_CLK.n4 7.17687
R42 ODD_CAPTURE_CLK.n26 ODD_CAPTURE_CLK.n14 7.10487
R43 ODD_CAPTURE_CLK.n23 ODD_CAPTURE_CLK.n14 4.42851
R44 ODD_CAPTURE_CLK.n18 ODD_CAPTURE_CLK.n17 4.42851
R45 ODD_CAPTURE_CLK.n6 ODD_CAPTURE_CLK.n5 4.42851
R46 ODD_CAPTURE_CLK.n20 ODD_CAPTURE_CLK.n19 0.1205
R47 ODD_CAPTURE_CLK.n20 ODD_CAPTURE_CLK.n15 0.1205
R48 ODD_CAPTURE_CLK.n25 ODD_CAPTURE_CLK.n15 0.1205
R49 ODD_CAPTURE_CLK.n4 ODD_CAPTURE_CLK.n3 0.1205
R50 ODD_CAPTURE_CLK.n3 ODD_CAPTURE_CLK.n2 0.1205
R51 ODD_CAPTURE_CLK.n2 ODD_CAPTURE_CLK.n1 0.1205
R52 ODD_CAPTURE_CLK.n12 ODD_CAPTURE_CLK.n1 0.1205
R53 ODD_CAPTURE_CLK.n26 ODD_CAPTURE_CLK.n25 0.0485
R54 ODD_CAPTURE_CLK.n13 ODD_CAPTURE_CLK.n12 0.0485
R55 EVEN_CAPTURE_CLK.n5 EVEN_CAPTURE_CLK.t7 113.632
R56 EVEN_CAPTURE_CLK.n14 EVEN_CAPTURE_CLK.t8 113.632
R57 EVEN_CAPTURE_CLK.n18 EVEN_CAPTURE_CLK.t15 113.632
R58 EVEN_CAPTURE_CLK.n0 EVEN_CAPTURE_CLK.t0 109.174
R59 EVEN_CAPTURE_CLK.n11 EVEN_CAPTURE_CLK.t1 109.174
R60 EVEN_CAPTURE_CLK.n6 EVEN_CAPTURE_CLK.t6 109.174
R61 EVEN_CAPTURE_CLK.n7 EVEN_CAPTURE_CLK.t5 109.174
R62 EVEN_CAPTURE_CLK.n8 EVEN_CAPTURE_CLK.t4 109.174
R63 EVEN_CAPTURE_CLK.n9 EVEN_CAPTURE_CLK.t3 109.174
R64 EVEN_CAPTURE_CLK.n10 EVEN_CAPTURE_CLK.t2 109.174
R65 EVEN_CAPTURE_CLK.n23 EVEN_CAPTURE_CLK.t9 109.174
R66 EVEN_CAPTURE_CLK.n24 EVEN_CAPTURE_CLK.t10 109.174
R67 EVEN_CAPTURE_CLK.n22 EVEN_CAPTURE_CLK.t11 109.174
R68 EVEN_CAPTURE_CLK.n21 EVEN_CAPTURE_CLK.t12 109.174
R69 EVEN_CAPTURE_CLK.n16 EVEN_CAPTURE_CLK.t13 109.174
R70 EVEN_CAPTURE_CLK.n17 EVEN_CAPTURE_CLK.t14 109.174
R71 EVEN_CAPTURE_CLK.n13 EVEN_CAPTURE_CLK.n0 18.5636
R72 EVEN_CAPTURE_CLK.n12 EVEN_CAPTURE_CLK.n11 18.4942
R73 EVEN_CAPTURE_CLK.n7 EVEN_CAPTURE_CLK.n4 18.4942
R74 EVEN_CAPTURE_CLK.n8 EVEN_CAPTURE_CLK.n3 18.4942
R75 EVEN_CAPTURE_CLK.n9 EVEN_CAPTURE_CLK.n2 18.4942
R76 EVEN_CAPTURE_CLK.n10 EVEN_CAPTURE_CLK.n1 18.4942
R77 EVEN_CAPTURE_CLK.n25 EVEN_CAPTURE_CLK.n24 18.4942
R78 EVEN_CAPTURE_CLK.n22 EVEN_CAPTURE_CLK.n15 18.4942
R79 EVEN_CAPTURE_CLK.n21 EVEN_CAPTURE_CLK.n20 18.4942
R80 EVEN_CAPTURE_CLK.n19 EVEN_CAPTURE_CLK.n16 18.4942
R81 EVEN_CAPTURE_CLK.n27 EVEN_CAPTURE_CLK.n13 18.4114
R82 EVEN_CAPTURE_CLK EVEN_CAPTURE_CLK.n27 14.0292
R83 EVEN_CAPTURE_CLK.n27 EVEN_CAPTURE_CLK.n26 13.5592
R84 EVEN_CAPTURE_CLK.n11 EVEN_CAPTURE_CLK.n0 11.6805
R85 EVEN_CAPTURE_CLK.n7 EVEN_CAPTURE_CLK.n6 11.6805
R86 EVEN_CAPTURE_CLK.n8 EVEN_CAPTURE_CLK.n7 11.6805
R87 EVEN_CAPTURE_CLK.n9 EVEN_CAPTURE_CLK.n8 11.6805
R88 EVEN_CAPTURE_CLK.n10 EVEN_CAPTURE_CLK.n9 11.6805
R89 EVEN_CAPTURE_CLK.n11 EVEN_CAPTURE_CLK.n10 11.6805
R90 EVEN_CAPTURE_CLK.n24 EVEN_CAPTURE_CLK.n23 11.6805
R91 EVEN_CAPTURE_CLK.n24 EVEN_CAPTURE_CLK.n22 11.6805
R92 EVEN_CAPTURE_CLK.n22 EVEN_CAPTURE_CLK.n21 11.6805
R93 EVEN_CAPTURE_CLK.n21 EVEN_CAPTURE_CLK.n16 11.6805
R94 EVEN_CAPTURE_CLK.n17 EVEN_CAPTURE_CLK.n16 11.6805
R95 EVEN_CAPTURE_CLK.n5 EVEN_CAPTURE_CLK.n4 7.17687
R96 EVEN_CAPTURE_CLK.n19 EVEN_CAPTURE_CLK.n18 7.17687
R97 EVEN_CAPTURE_CLK.n26 EVEN_CAPTURE_CLK.n14 7.10487
R98 EVEN_CAPTURE_CLK.n6 EVEN_CAPTURE_CLK.n5 4.42851
R99 EVEN_CAPTURE_CLK.n23 EVEN_CAPTURE_CLK.n14 4.42851
R100 EVEN_CAPTURE_CLK.n18 EVEN_CAPTURE_CLK.n17 4.42851
R101 EVEN_CAPTURE_CLK.n4 EVEN_CAPTURE_CLK.n3 0.1205
R102 EVEN_CAPTURE_CLK.n3 EVEN_CAPTURE_CLK.n2 0.1205
R103 EVEN_CAPTURE_CLK.n2 EVEN_CAPTURE_CLK.n1 0.1205
R104 EVEN_CAPTURE_CLK.n12 EVEN_CAPTURE_CLK.n1 0.1205
R105 EVEN_CAPTURE_CLK.n20 EVEN_CAPTURE_CLK.n19 0.1205
R106 EVEN_CAPTURE_CLK.n20 EVEN_CAPTURE_CLK.n15 0.1205
R107 EVEN_CAPTURE_CLK.n25 EVEN_CAPTURE_CLK.n15 0.1205
R108 EVEN_CAPTURE_CLK.n13 EVEN_CAPTURE_CLK.n12 0.0485
R109 EVEN_CAPTURE_CLK.n26 EVEN_CAPTURE_CLK.n25 0.0485
R110 ODD_DB.n16 ODD_DB.t3 113.632
R111 ODD_DB.n13 ODD_DB.t0 113.632
R112 ODD_DB.n6 ODD_DB.t4 113.632
R113 ODD_DB.n2 ODD_DB.t11 113.632
R114 ODD_DB.n14 ODD_DB.t1 109.174
R115 ODD_DB.n15 ODD_DB.t2 109.174
R116 ODD_DB.n7 ODD_DB.t5 109.174
R117 ODD_DB.n8 ODD_DB.t6 109.174
R118 ODD_DB.n9 ODD_DB.t7 109.174
R119 ODD_DB.n10 ODD_DB.t8 109.174
R120 ODD_DB.n4 ODD_DB.t9 109.174
R121 ODD_DB.n3 ODD_DB.t10 109.174
R122 ODD_DB.n8 ODD_DB.n5 18.4942
R123 ODD_DB.n9 ODD_DB.n0 18.4942
R124 ODD_DB.n11 ODD_DB.n10 18.4942
R125 ODD_DB.n4 ODD_DB.n1 18.4942
R126 ODD_DB ODD_DB.n18 16.4748
R127 ODD_DB.n18 ODD_DB.n12 14.8701
R128 ODD_DB.n15 ODD_DB.n14 11.6805
R129 ODD_DB.n8 ODD_DB.n7 11.6805
R130 ODD_DB.n9 ODD_DB.n8 11.6805
R131 ODD_DB.n10 ODD_DB.n9 11.6805
R132 ODD_DB.n10 ODD_DB.n4 11.6805
R133 ODD_DB.n4 ODD_DB.n3 11.6805
R134 ODD_DB.n18 ODD_DB.n17 9.0005
R135 ODD_DB.n6 ODD_DB.n5 7.17687
R136 ODD_DB.n2 ODD_DB.n1 7.17687
R137 ODD_DB.n17 ODD_DB.n13 7.10487
R138 ODD_DB.n17 ODD_DB.n16 7.10487
R139 ODD_DB.n14 ODD_DB.n13 4.42851
R140 ODD_DB.n16 ODD_DB.n15 4.42851
R141 ODD_DB.n7 ODD_DB.n6 4.42851
R142 ODD_DB.n3 ODD_DB.n2 4.42851
R143 ODD_DB.n5 ODD_DB.n0 0.1205
R144 ODD_DB.n11 ODD_DB.n1 0.1205
R145 ODD_DB.n12 ODD_DB.n0 0.0485
R146 ODD_DB.n12 ODD_DB.n11 0.0485
R147 ODD_D.n16 ODD_D.t3 113.632
R148 ODD_D.n13 ODD_D.t0 113.632
R149 ODD_D.n6 ODD_D.t4 113.632
R150 ODD_D.n2 ODD_D.t11 113.632
R151 ODD_D.n14 ODD_D.t1 109.174
R152 ODD_D.n15 ODD_D.t2 109.174
R153 ODD_D.n7 ODD_D.t5 109.174
R154 ODD_D.n8 ODD_D.t6 109.174
R155 ODD_D.n9 ODD_D.t7 109.174
R156 ODD_D.n10 ODD_D.t8 109.174
R157 ODD_D.n4 ODD_D.t9 109.174
R158 ODD_D.n3 ODD_D.t10 109.174
R159 ODD_D ODD_D.n18 18.7053
R160 ODD_D.n8 ODD_D.n5 18.4942
R161 ODD_D.n9 ODD_D.n0 18.4942
R162 ODD_D.n11 ODD_D.n10 18.4942
R163 ODD_D.n4 ODD_D.n1 18.4942
R164 ODD_D.n18 ODD_D.n12 14.8701
R165 ODD_D.n15 ODD_D.n14 11.6805
R166 ODD_D.n8 ODD_D.n7 11.6805
R167 ODD_D.n9 ODD_D.n8 11.6805
R168 ODD_D.n10 ODD_D.n9 11.6805
R169 ODD_D.n10 ODD_D.n4 11.6805
R170 ODD_D.n4 ODD_D.n3 11.6805
R171 ODD_D.n18 ODD_D.n17 9.0005
R172 ODD_D.n6 ODD_D.n5 7.17687
R173 ODD_D.n2 ODD_D.n1 7.17687
R174 ODD_D.n17 ODD_D.n13 7.10487
R175 ODD_D.n17 ODD_D.n16 7.10487
R176 ODD_D.n14 ODD_D.n13 4.42851
R177 ODD_D.n16 ODD_D.n15 4.42851
R178 ODD_D.n7 ODD_D.n6 4.42851
R179 ODD_D.n3 ODD_D.n2 4.42851
R180 ODD_D.n5 ODD_D.n0 0.1205
R181 ODD_D.n11 ODD_D.n1 0.1205
R182 ODD_D.n12 ODD_D.n0 0.0485
R183 ODD_D.n12 ODD_D.n11 0.0485
R184 EVEN_D.n16 EVEN_D.t3 113.632
R185 EVEN_D.n13 EVEN_D.t0 113.632
R186 EVEN_D.n6 EVEN_D.t4 113.632
R187 EVEN_D.n2 EVEN_D.t11 113.632
R188 EVEN_D.n14 EVEN_D.t1 109.174
R189 EVEN_D.n15 EVEN_D.t2 109.174
R190 EVEN_D.n7 EVEN_D.t5 109.174
R191 EVEN_D.n8 EVEN_D.t6 109.174
R192 EVEN_D.n9 EVEN_D.t7 109.174
R193 EVEN_D.n10 EVEN_D.t8 109.174
R194 EVEN_D.n4 EVEN_D.t9 109.174
R195 EVEN_D.n3 EVEN_D.t10 109.174
R196 EVEN_D EVEN_D.n18 19.6444
R197 EVEN_D.n8 EVEN_D.n5 18.4942
R198 EVEN_D.n9 EVEN_D.n0 18.4942
R199 EVEN_D.n11 EVEN_D.n10 18.4942
R200 EVEN_D.n4 EVEN_D.n1 18.4942
R201 EVEN_D.n18 EVEN_D.n12 14.8701
R202 EVEN_D.n15 EVEN_D.n14 11.6805
R203 EVEN_D.n8 EVEN_D.n7 11.6805
R204 EVEN_D.n9 EVEN_D.n8 11.6805
R205 EVEN_D.n10 EVEN_D.n9 11.6805
R206 EVEN_D.n10 EVEN_D.n4 11.6805
R207 EVEN_D.n4 EVEN_D.n3 11.6805
R208 EVEN_D.n18 EVEN_D.n17 9.0005
R209 EVEN_D.n6 EVEN_D.n5 7.17687
R210 EVEN_D.n2 EVEN_D.n1 7.17687
R211 EVEN_D.n17 EVEN_D.n13 7.10487
R212 EVEN_D.n17 EVEN_D.n16 7.10487
R213 EVEN_D.n14 EVEN_D.n13 4.42851
R214 EVEN_D.n16 EVEN_D.n15 4.42851
R215 EVEN_D.n7 EVEN_D.n6 4.42851
R216 EVEN_D.n3 EVEN_D.n2 4.42851
R217 EVEN_D.n5 EVEN_D.n0 0.1205
R218 EVEN_D.n11 EVEN_D.n1 0.1205
R219 EVEN_D.n12 EVEN_D.n0 0.0485
R220 EVEN_D.n12 EVEN_D.n11 0.0485
R221 EVEN_DB.n16 EVEN_DB.t3 113.632
R222 EVEN_DB.n13 EVEN_DB.t0 113.632
R223 EVEN_DB.n6 EVEN_DB.t4 113.632
R224 EVEN_DB.n2 EVEN_DB.t11 113.632
R225 EVEN_DB.n14 EVEN_DB.t1 109.174
R226 EVEN_DB.n15 EVEN_DB.t2 109.174
R227 EVEN_DB.n7 EVEN_DB.t5 109.174
R228 EVEN_DB.n8 EVEN_DB.t6 109.174
R229 EVEN_DB.n9 EVEN_DB.t7 109.174
R230 EVEN_DB.n10 EVEN_DB.t8 109.174
R231 EVEN_DB.n4 EVEN_DB.t9 109.174
R232 EVEN_DB.n3 EVEN_DB.t10 109.174
R233 EVEN_DB.n8 EVEN_DB.n5 18.4942
R234 EVEN_DB.n9 EVEN_DB.n0 18.4942
R235 EVEN_DB.n11 EVEN_DB.n10 18.4942
R236 EVEN_DB.n4 EVEN_DB.n1 18.4942
R237 EVEN_DB EVEN_DB.n18 16.6314
R238 EVEN_DB.n18 EVEN_DB.n12 14.8701
R239 EVEN_DB.n15 EVEN_DB.n14 11.6805
R240 EVEN_DB.n8 EVEN_DB.n7 11.6805
R241 EVEN_DB.n9 EVEN_DB.n8 11.6805
R242 EVEN_DB.n10 EVEN_DB.n9 11.6805
R243 EVEN_DB.n10 EVEN_DB.n4 11.6805
R244 EVEN_DB.n4 EVEN_DB.n3 11.6805
R245 EVEN_DB.n18 EVEN_DB.n17 9.0005
R246 EVEN_DB.n6 EVEN_DB.n5 7.17687
R247 EVEN_DB.n2 EVEN_DB.n1 7.17687
R248 EVEN_DB.n17 EVEN_DB.n13 7.10487
R249 EVEN_DB.n17 EVEN_DB.n16 7.10487
R250 EVEN_DB.n14 EVEN_DB.n13 4.42851
R251 EVEN_DB.n16 EVEN_DB.n15 4.42851
R252 EVEN_DB.n7 EVEN_DB.n6 4.42851
R253 EVEN_DB.n3 EVEN_DB.n2 4.42851
R254 EVEN_DB.n5 EVEN_DB.n0 0.1205
R255 EVEN_DB.n11 EVEN_DB.n1 0.1205
R256 EVEN_DB.n12 EVEN_DB.n0 0.0485
R257 EVEN_DB.n12 EVEN_DB.n11 0.0485
R258 ODD_Q.n5 ODD_Q.n2 12.9918
R259 ODD_Q ODD_Q.n5 10.5466
R260 ODD_Q.n1 ODD_Q.t6 5.73764
R261 ODD_Q.n2 ODD_Q.t2 5.6429
R262 ODD_Q.n4 ODD_Q.t3 5.63749
R263 ODD_Q.n4 ODD_Q.n3 5.52748
R264 ODD_Q.n1 ODD_Q.n0 5.32067
R265 ODD_Q.n5 ODD_Q.n4 4.61789
R266 ODD_Q.n0 ODD_Q.t4 0.228
R267 ODD_Q.n0 ODD_Q.t1 0.228
R268 ODD_Q.n3 ODD_Q.t5 0.20525
R269 ODD_Q.n3 ODD_Q.t0 0.20525
R270 ODD_Q.n2 ODD_Q.n1 0.0952368
R271 ODD_QB ODD_QB.n5 21.5031
R272 ODD_QB.n5 ODD_QB.n2 12.7179
R273 ODD_QB.n1 ODD_QB.t2 5.73764
R274 ODD_QB.n2 ODD_QB.t1 5.6429
R275 ODD_QB.n4 ODD_QB.t4 5.63749
R276 ODD_QB.n4 ODD_QB.n3 5.52748
R277 ODD_QB.n1 ODD_QB.n0 5.32067
R278 ODD_QB.n5 ODD_QB.n4 4.8918
R279 ODD_QB.n0 ODD_QB.t3 0.228
R280 ODD_QB.n0 ODD_QB.t6 0.228
R281 ODD_QB.n3 ODD_QB.t0 0.20525
R282 ODD_QB.n3 ODD_QB.t5 0.20525
R283 ODD_QB.n2 ODD_QB.n1 0.0952368
R284 EVEN_QB EVEN_QB.n5 20.9553
R285 EVEN_QB.n5 EVEN_QB.n2 13.1092
R286 EVEN_QB.n1 EVEN_QB.t4 5.73764
R287 EVEN_QB.n2 EVEN_QB.t0 5.6429
R288 EVEN_QB.n4 EVEN_QB.t3 5.63749
R289 EVEN_QB.n4 EVEN_QB.n3 5.52748
R290 EVEN_QB.n1 EVEN_QB.n0 5.32067
R291 EVEN_QB.n5 EVEN_QB.n4 4.5005
R292 EVEN_QB.n0 EVEN_QB.t5 0.228
R293 EVEN_QB.n0 EVEN_QB.t6 0.228
R294 EVEN_QB.n3 EVEN_QB.t1 0.20525
R295 EVEN_QB.n3 EVEN_QB.t2 0.20525
R296 EVEN_QB.n2 EVEN_QB.n1 0.0952368
R297 EVEN_Q.n5 EVEN_Q.n2 13.1092
R298 EVEN_Q EVEN_Q.n5 11.0553
R299 EVEN_Q.n1 EVEN_Q.t5 5.73764
R300 EVEN_Q.n2 EVEN_Q.t4 5.6429
R301 EVEN_Q.n4 EVEN_Q.t1 5.63749
R302 EVEN_Q.n4 EVEN_Q.n3 5.52748
R303 EVEN_Q.n1 EVEN_Q.n0 5.32067
R304 EVEN_Q.n5 EVEN_Q.n4 4.5005
R305 EVEN_Q.n0 EVEN_Q.t6 0.228
R306 EVEN_Q.n0 EVEN_Q.t0 0.228
R307 EVEN_Q.n3 EVEN_Q.t2 0.20525
R308 EVEN_Q.n3 EVEN_Q.t3 0.20525
R309 EVEN_Q.n2 EVEN_Q.n1 0.0952368
R310 ODD_CAPTURE_CLKB.n17 ODD_CAPTURE_CLKB.t0 113.632
R311 ODD_CAPTURE_CLKB.n5 ODD_CAPTURE_CLKB.t8 113.632
R312 ODD_CAPTURE_CLKB.n26 ODD_CAPTURE_CLKB.t7 109.174
R313 ODD_CAPTURE_CLKB.n25 ODD_CAPTURE_CLKB.t6 109.174
R314 ODD_CAPTURE_CLKB.n24 ODD_CAPTURE_CLKB.t5 109.174
R315 ODD_CAPTURE_CLKB.n15 ODD_CAPTURE_CLKB.t4 109.174
R316 ODD_CAPTURE_CLKB.n20 ODD_CAPTURE_CLKB.t3 109.174
R317 ODD_CAPTURE_CLKB.n19 ODD_CAPTURE_CLKB.t2 109.174
R318 ODD_CAPTURE_CLKB.n18 ODD_CAPTURE_CLKB.t1 109.174
R319 ODD_CAPTURE_CLKB.n6 ODD_CAPTURE_CLKB.t9 109.174
R320 ODD_CAPTURE_CLKB.n7 ODD_CAPTURE_CLKB.t10 109.174
R321 ODD_CAPTURE_CLKB.n8 ODD_CAPTURE_CLKB.t11 109.174
R322 ODD_CAPTURE_CLKB.n9 ODD_CAPTURE_CLKB.t12 109.174
R323 ODD_CAPTURE_CLKB.n10 ODD_CAPTURE_CLKB.t13 109.174
R324 ODD_CAPTURE_CLKB.n11 ODD_CAPTURE_CLKB.t14 109.174
R325 ODD_CAPTURE_CLKB.n12 ODD_CAPTURE_CLKB.t15 109.174
R326 ODD_CAPTURE_CLKB ODD_CAPTURE_CLKB.n28 21.6792
R327 ODD_CAPTURE_CLKB.n27 ODD_CAPTURE_CLKB.n26 18.4942
R328 ODD_CAPTURE_CLKB.n25 ODD_CAPTURE_CLKB.n14 18.4942
R329 ODD_CAPTURE_CLKB.n24 ODD_CAPTURE_CLKB.n23 18.4942
R330 ODD_CAPTURE_CLKB.n22 ODD_CAPTURE_CLKB.n15 18.4942
R331 ODD_CAPTURE_CLKB.n21 ODD_CAPTURE_CLKB.n20 18.4942
R332 ODD_CAPTURE_CLKB.n19 ODD_CAPTURE_CLKB.n16 18.4942
R333 ODD_CAPTURE_CLKB.n7 ODD_CAPTURE_CLKB.n4 18.4942
R334 ODD_CAPTURE_CLKB.n8 ODD_CAPTURE_CLKB.n3 18.4942
R335 ODD_CAPTURE_CLKB.n9 ODD_CAPTURE_CLKB.n2 18.4942
R336 ODD_CAPTURE_CLKB.n10 ODD_CAPTURE_CLKB.n1 18.4942
R337 ODD_CAPTURE_CLKB.n11 ODD_CAPTURE_CLKB.n0 18.4942
R338 ODD_CAPTURE_CLKB.n13 ODD_CAPTURE_CLKB.n12 18.4942
R339 ODD_CAPTURE_CLKB.n28 ODD_CAPTURE_CLKB.n13 14.2555
R340 ODD_CAPTURE_CLKB.n26 ODD_CAPTURE_CLKB.n25 11.6805
R341 ODD_CAPTURE_CLKB.n25 ODD_CAPTURE_CLKB.n24 11.6805
R342 ODD_CAPTURE_CLKB.n24 ODD_CAPTURE_CLKB.n15 11.6805
R343 ODD_CAPTURE_CLKB.n20 ODD_CAPTURE_CLKB.n15 11.6805
R344 ODD_CAPTURE_CLKB.n20 ODD_CAPTURE_CLKB.n19 11.6805
R345 ODD_CAPTURE_CLKB.n19 ODD_CAPTURE_CLKB.n18 11.6805
R346 ODD_CAPTURE_CLKB.n7 ODD_CAPTURE_CLKB.n6 11.6805
R347 ODD_CAPTURE_CLKB.n8 ODD_CAPTURE_CLKB.n7 11.6805
R348 ODD_CAPTURE_CLKB.n9 ODD_CAPTURE_CLKB.n8 11.6805
R349 ODD_CAPTURE_CLKB.n10 ODD_CAPTURE_CLKB.n9 11.6805
R350 ODD_CAPTURE_CLKB.n11 ODD_CAPTURE_CLKB.n10 11.6805
R351 ODD_CAPTURE_CLKB.n12 ODD_CAPTURE_CLKB.n11 11.6805
R352 ODD_CAPTURE_CLKB.n28 ODD_CAPTURE_CLKB.n27 9.1685
R353 ODD_CAPTURE_CLKB.n17 ODD_CAPTURE_CLKB.n16 7.17687
R354 ODD_CAPTURE_CLKB.n5 ODD_CAPTURE_CLKB.n4 7.17687
R355 ODD_CAPTURE_CLKB.n18 ODD_CAPTURE_CLKB.n17 4.42851
R356 ODD_CAPTURE_CLKB.n6 ODD_CAPTURE_CLKB.n5 4.42851
R357 ODD_CAPTURE_CLKB.n27 ODD_CAPTURE_CLKB.n14 0.1205
R358 ODD_CAPTURE_CLKB.n23 ODD_CAPTURE_CLKB.n14 0.1205
R359 ODD_CAPTURE_CLKB.n23 ODD_CAPTURE_CLKB.n22 0.1205
R360 ODD_CAPTURE_CLKB.n22 ODD_CAPTURE_CLKB.n21 0.1205
R361 ODD_CAPTURE_CLKB.n21 ODD_CAPTURE_CLKB.n16 0.1205
R362 ODD_CAPTURE_CLKB.n13 ODD_CAPTURE_CLKB.n0 0.1205
R363 ODD_CAPTURE_CLKB.n1 ODD_CAPTURE_CLKB.n0 0.1205
R364 ODD_CAPTURE_CLKB.n2 ODD_CAPTURE_CLKB.n1 0.1205
R365 ODD_CAPTURE_CLKB.n3 ODD_CAPTURE_CLKB.n2 0.1205
R366 ODD_CAPTURE_CLKB.n4 ODD_CAPTURE_CLKB.n3 0.1205
R367 EVEN_CAPTURE_CLKB.n17 EVEN_CAPTURE_CLKB.t0 113.632
R368 EVEN_CAPTURE_CLKB.n5 EVEN_CAPTURE_CLKB.t8 113.632
R369 EVEN_CAPTURE_CLKB.n26 EVEN_CAPTURE_CLKB.t7 109.174
R370 EVEN_CAPTURE_CLKB.n25 EVEN_CAPTURE_CLKB.t6 109.174
R371 EVEN_CAPTURE_CLKB.n24 EVEN_CAPTURE_CLKB.t5 109.174
R372 EVEN_CAPTURE_CLKB.n15 EVEN_CAPTURE_CLKB.t4 109.174
R373 EVEN_CAPTURE_CLKB.n20 EVEN_CAPTURE_CLKB.t3 109.174
R374 EVEN_CAPTURE_CLKB.n19 EVEN_CAPTURE_CLKB.t2 109.174
R375 EVEN_CAPTURE_CLKB.n18 EVEN_CAPTURE_CLKB.t1 109.174
R376 EVEN_CAPTURE_CLKB.n6 EVEN_CAPTURE_CLKB.t9 109.174
R377 EVEN_CAPTURE_CLKB.n7 EVEN_CAPTURE_CLKB.t10 109.174
R378 EVEN_CAPTURE_CLKB.n8 EVEN_CAPTURE_CLKB.t11 109.174
R379 EVEN_CAPTURE_CLKB.n9 EVEN_CAPTURE_CLKB.t12 109.174
R380 EVEN_CAPTURE_CLKB.n10 EVEN_CAPTURE_CLKB.t13 109.174
R381 EVEN_CAPTURE_CLKB.n11 EVEN_CAPTURE_CLKB.t14 109.174
R382 EVEN_CAPTURE_CLKB.n12 EVEN_CAPTURE_CLKB.t15 109.174
R383 EVEN_CAPTURE_CLKB EVEN_CAPTURE_CLKB.n28 22.5792
R384 EVEN_CAPTURE_CLKB.n27 EVEN_CAPTURE_CLKB.n26 18.4942
R385 EVEN_CAPTURE_CLKB.n25 EVEN_CAPTURE_CLKB.n14 18.4942
R386 EVEN_CAPTURE_CLKB.n24 EVEN_CAPTURE_CLKB.n23 18.4942
R387 EVEN_CAPTURE_CLKB.n22 EVEN_CAPTURE_CLKB.n15 18.4942
R388 EVEN_CAPTURE_CLKB.n21 EVEN_CAPTURE_CLKB.n20 18.4942
R389 EVEN_CAPTURE_CLKB.n19 EVEN_CAPTURE_CLKB.n16 18.4942
R390 EVEN_CAPTURE_CLKB.n7 EVEN_CAPTURE_CLKB.n4 18.4942
R391 EVEN_CAPTURE_CLKB.n8 EVEN_CAPTURE_CLKB.n3 18.4942
R392 EVEN_CAPTURE_CLKB.n9 EVEN_CAPTURE_CLKB.n2 18.4942
R393 EVEN_CAPTURE_CLKB.n10 EVEN_CAPTURE_CLKB.n1 18.4942
R394 EVEN_CAPTURE_CLKB.n11 EVEN_CAPTURE_CLKB.n0 18.4942
R395 EVEN_CAPTURE_CLKB.n13 EVEN_CAPTURE_CLKB.n12 18.4942
R396 EVEN_CAPTURE_CLKB.n28 EVEN_CAPTURE_CLKB.n13 14.2555
R397 EVEN_CAPTURE_CLKB.n26 EVEN_CAPTURE_CLKB.n25 11.6805
R398 EVEN_CAPTURE_CLKB.n25 EVEN_CAPTURE_CLKB.n24 11.6805
R399 EVEN_CAPTURE_CLKB.n24 EVEN_CAPTURE_CLKB.n15 11.6805
R400 EVEN_CAPTURE_CLKB.n20 EVEN_CAPTURE_CLKB.n15 11.6805
R401 EVEN_CAPTURE_CLKB.n20 EVEN_CAPTURE_CLKB.n19 11.6805
R402 EVEN_CAPTURE_CLKB.n19 EVEN_CAPTURE_CLKB.n18 11.6805
R403 EVEN_CAPTURE_CLKB.n7 EVEN_CAPTURE_CLKB.n6 11.6805
R404 EVEN_CAPTURE_CLKB.n8 EVEN_CAPTURE_CLKB.n7 11.6805
R405 EVEN_CAPTURE_CLKB.n9 EVEN_CAPTURE_CLKB.n8 11.6805
R406 EVEN_CAPTURE_CLKB.n10 EVEN_CAPTURE_CLKB.n9 11.6805
R407 EVEN_CAPTURE_CLKB.n11 EVEN_CAPTURE_CLKB.n10 11.6805
R408 EVEN_CAPTURE_CLKB.n12 EVEN_CAPTURE_CLKB.n11 11.6805
R409 EVEN_CAPTURE_CLKB.n28 EVEN_CAPTURE_CLKB.n27 9.1685
R410 EVEN_CAPTURE_CLKB.n17 EVEN_CAPTURE_CLKB.n16 7.17687
R411 EVEN_CAPTURE_CLKB.n5 EVEN_CAPTURE_CLKB.n4 7.17687
R412 EVEN_CAPTURE_CLKB.n18 EVEN_CAPTURE_CLKB.n17 4.42851
R413 EVEN_CAPTURE_CLKB.n6 EVEN_CAPTURE_CLKB.n5 4.42851
R414 EVEN_CAPTURE_CLKB.n27 EVEN_CAPTURE_CLKB.n14 0.1205
R415 EVEN_CAPTURE_CLKB.n23 EVEN_CAPTURE_CLKB.n14 0.1205
R416 EVEN_CAPTURE_CLKB.n23 EVEN_CAPTURE_CLKB.n22 0.1205
R417 EVEN_CAPTURE_CLKB.n22 EVEN_CAPTURE_CLKB.n21 0.1205
R418 EVEN_CAPTURE_CLKB.n21 EVEN_CAPTURE_CLKB.n16 0.1205
R419 EVEN_CAPTURE_CLKB.n13 EVEN_CAPTURE_CLKB.n0 0.1205
R420 EVEN_CAPTURE_CLKB.n1 EVEN_CAPTURE_CLKB.n0 0.1205
R421 EVEN_CAPTURE_CLKB.n2 EVEN_CAPTURE_CLKB.n1 0.1205
R422 EVEN_CAPTURE_CLKB.n3 EVEN_CAPTURE_CLKB.n2 0.1205
R423 EVEN_CAPTURE_CLKB.n4 EVEN_CAPTURE_CLKB.n3 0.1205
R424 VDD.n57 VDD.n54 166.667
R425 VDD.n54 VDD.n53 166.667
R426 VDD.t128 VDD.n55 126.668
R427 VDD.n44 VDD.t114 126.668
R428 VDD.t166 VDD.n79 113.334
R429 VDD.n71 VDD.t110 113.334
R430 VDD.t17 VDD.n38 113.334
R431 VDD.n30 VDD.t112 113.334
R432 VDD.n82 VDD.n81 106.3
R433 VDD.n27 VDD.n26 106.3
R434 VDD.n82 VDD.n3 70.0005
R435 VDD.n78 VDD.n3 70.0005
R436 VDD.n78 VDD.n4 70.0005
R437 VDD.n72 VDD.n4 70.0005
R438 VDD.n72 VDD.n8 70.0005
R439 VDD.n64 VDD.n8 70.0005
R440 VDD.n64 VDD.n10 70.0005
R441 VDD.n58 VDD.n10 70.0005
R442 VDD.n58 VDD.n14 70.0005
R443 VDD.n52 VDD.n14 70.0005
R444 VDD.n52 VDD.n15 70.0005
R445 VDD.n46 VDD.n15 70.0005
R446 VDD.n46 VDD.n19 70.0005
R447 VDD.n37 VDD.n19 70.0005
R448 VDD.n37 VDD.n21 70.0005
R449 VDD.n31 VDD.n21 70.0005
R450 VDD.n31 VDD.n25 70.0005
R451 VDD.n26 VDD.n25 70.0005
R452 VDD.n81 VDD.n80 66.6672
R453 VDD.n67 VDD.n66 66.6672
R454 VDD.n40 VDD.n39 66.6672
R455 VDD.n28 VDD.n27 66.6672
R456 VDD.n70 VDD.t38 53.3338
R457 VDD.t84 VDD.n70 53.3338
R458 VDD.n67 VDD.t135 53.3338
R459 VDD.n40 VDD.t54 53.3338
R460 VDD.n29 VDD.t76 53.3338
R461 VDD.t96 VDD.n29 53.3338
R462 VDD.n55 VDD.t124 46.6672
R463 VDD.t20 VDD.n44 46.6672
R464 VDD.t7 VDD.t149 33.3338
R465 VDD.t46 VDD.t22 33.3338
R466 VDD.n57 VDD.t126 26.6672
R467 VDD.n53 VDD.t116 26.6672
R468 VDD.n132 VDD.n131 25.203
R469 VDD.n168 VDD.n167 25.203
R470 VDD.n155 VDD.n154 22.1735
R471 VDD.n79 VDD.t24 20.0005
R472 VDD.n71 VDD.t94 20.0005
R473 VDD.n38 VDD.t68 20.0005
R474 VDD.n30 VDD.t108 20.0005
R475 VDD.n117 VDD.n110 19.5039
R476 VDD.n186 VDD.n179 19.5039
R477 VDD.n123 VDD.n121 19.4092
R478 VDD.n130 VDD.n129 19.4092
R479 VDD.n171 VDD.n169 19.4092
R480 VDD.n178 VDD.n177 19.4092
R481 VDD.n84 VDD.n83 18.3116
R482 VDD.n2 VDD.n1 18.0005
R483 VDD.n77 VDD.n76 18.0005
R484 VDD.n75 VDD.n5 18.0005
R485 VDD.n74 VDD.n73 18.0005
R486 VDD.n7 VDD.n6 18.0005
R487 VDD.n63 VDD.n62 18.0005
R488 VDD.n61 VDD.n11 18.0005
R489 VDD.n60 VDD.n59 18.0005
R490 VDD.n13 VDD.n12 18.0005
R491 VDD.n51 VDD.n50 18.0005
R492 VDD.n49 VDD.n16 18.0005
R493 VDD.n48 VDD.n47 18.0005
R494 VDD.n18 VDD.n17 18.0005
R495 VDD.n36 VDD.n35 18.0005
R496 VDD.n34 VDD.n22 18.0005
R497 VDD.n33 VDD.n32 18.0005
R498 VDD.n27 VDD.n20 17.6849
R499 VDD.n141 VDD.n133 16.9481
R500 VDD.n81 VDD.n0 16.4744
R501 VDD.n29 VDD.n20 16.4218
R502 VDD.n41 VDD.n40 16.4218
R503 VDD.n43 VDD.n42 16.4218
R504 VDD.n56 VDD.n9 16.4218
R505 VDD.n68 VDD.n67 16.4218
R506 VDD.n70 VDD.n69 16.4218
R507 VDD.n110 VDD.n109 14.6703
R508 VDD.n105 VDD.n101 13.7564
R509 VDD.n193 VDD.n192 13.4387
R510 VDD.n80 VDD.t164 13.3338
R511 VDD.t164 VDD.t168 13.3338
R512 VDD.t168 VDD.t118 13.3338
R513 VDD.t118 VDD.t166 13.3338
R514 VDD.t26 VDD.t24 13.3338
R515 VDD.t28 VDD.t26 13.3338
R516 VDD.t32 VDD.t28 13.3338
R517 VDD.t30 VDD.t32 13.3338
R518 VDD.t34 VDD.t30 13.3338
R519 VDD.t36 VDD.t34 13.3338
R520 VDD.t38 VDD.t36 13.3338
R521 VDD.t80 VDD.t84 13.3338
R522 VDD.t86 VDD.t80 13.3338
R523 VDD.t90 VDD.t86 13.3338
R524 VDD.t88 VDD.t90 13.3338
R525 VDD.t92 VDD.t88 13.3338
R526 VDD.t82 VDD.t92 13.3338
R527 VDD.t94 VDD.t82 13.3338
R528 VDD.t15 VDD.t110 13.3338
R529 VDD.t13 VDD.t15 13.3338
R530 VDD.t130 VDD.t13 13.3338
R531 VDD.n66 VDD.t130 13.3338
R532 VDD.t135 VDD.t138 13.3338
R533 VDD.t138 VDD.t140 13.3338
R534 VDD.t140 VDD.t142 13.3338
R535 VDD.t145 VDD.t120 13.3338
R536 VDD.t147 VDD.t145 13.3338
R537 VDD.t149 VDD.t147 13.3338
R538 VDD.t131 VDD.t7 13.3338
R539 VDD.t133 VDD.t131 13.3338
R540 VDD.t124 VDD.t133 13.3338
R541 VDD.t78 VDD.t20 13.3338
R542 VDD.t158 VDD.t78 13.3338
R543 VDD.t22 VDD.t158 13.3338
R544 VDD.t40 VDD.t46 13.3338
R545 VDD.t49 VDD.t40 13.3338
R546 VDD.t2 VDD.t49 13.3338
R547 VDD.t52 VDD.t0 13.3338
R548 VDD.t43 VDD.t52 13.3338
R549 VDD.t54 VDD.t43 13.3338
R550 VDD.n39 VDD.t5 13.3338
R551 VDD.t5 VDD.t4 13.3338
R552 VDD.t4 VDD.t6 13.3338
R553 VDD.t6 VDD.t17 13.3338
R554 VDD.t66 VDD.t68 13.3338
R555 VDD.t64 VDD.t66 13.3338
R556 VDD.t62 VDD.t64 13.3338
R557 VDD.t72 VDD.t62 13.3338
R558 VDD.t74 VDD.t72 13.3338
R559 VDD.t70 VDD.t74 13.3338
R560 VDD.t76 VDD.t70 13.3338
R561 VDD.t98 VDD.t96 13.3338
R562 VDD.t101 VDD.t98 13.3338
R563 VDD.t11 VDD.t101 13.3338
R564 VDD.t9 VDD.t11 13.3338
R565 VDD.t104 VDD.t9 13.3338
R566 VDD.t106 VDD.t104 13.3338
R567 VDD.t108 VDD.t106 13.3338
R568 VDD.t112 VDD.t160 13.3338
R569 VDD.t160 VDD.t18 13.3338
R570 VDD.t18 VDD.t162 13.3338
R571 VDD.t162 VDD.n28 13.3338
R572 VDD.n142 VDD.n106 13.2291
R573 VDD.n99 VDD.n86 13.2291
R574 VDD.n164 VDD.n156 12.3348
R575 VDD.n120 VDD.n119 11.9744
R576 VDD.n189 VDD.n188 11.9744
R577 VDD.n119 VDD.n118 10.1049
R578 VDD.n188 VDD.n187 10.1049
R579 VDD.n33 VDD.n23 9.31191
R580 VDD.n90 VDD.n85 8.84398
R581 VDD.n98 VDD.n90 8.00988
R582 VDD.n119 VDD.n117 7.43528
R583 VDD.n188 VDD.n186 7.43528
R584 VDD.n143 VDD.n100 6.88746
R585 VDD.n153 VDD.n152 6.88746
R586 VDD.n166 VDD.n165 6.88746
R587 VDD.n26 VDD.n23 6.79358
R588 VDD.t142 VDD.n65 6.66717
R589 VDD.n65 VDD.t120 6.66717
R590 VDD.n56 VDD.t128 6.66717
R591 VDD.t126 VDD.n56 6.66717
R592 VDD.n43 VDD.t116 6.66717
R593 VDD.t114 VDD.n43 6.66717
R594 VDD.n45 VDD.t2 6.66717
R595 VDD.n45 VDD.t0 6.66717
R596 VDD.n83 VDD.n82 6.3005
R597 VDD.n80 VDD.n3 6.3005
R598 VDD.n3 VDD.n2 6.3005
R599 VDD.n79 VDD.n78 6.3005
R600 VDD.n78 VDD.n77 6.3005
R601 VDD.n70 VDD.n4 6.3005
R602 VDD.n5 VDD.n4 6.3005
R603 VDD.n72 VDD.n71 6.3005
R604 VDD.n73 VDD.n72 6.3005
R605 VDD.n66 VDD.n8 6.3005
R606 VDD.n8 VDD.n7 6.3005
R607 VDD.n65 VDD.n64 6.3005
R608 VDD.n64 VDD.n63 6.3005
R609 VDD.n55 VDD.n10 6.3005
R610 VDD.n11 VDD.n10 6.3005
R611 VDD.n58 VDD.n57 6.3005
R612 VDD.n59 VDD.n58 6.3005
R613 VDD.n54 VDD.n14 6.3005
R614 VDD.n14 VDD.n13 6.3005
R615 VDD.n53 VDD.n52 6.3005
R616 VDD.n52 VDD.n51 6.3005
R617 VDD.n44 VDD.n15 6.3005
R618 VDD.n16 VDD.n15 6.3005
R619 VDD.n46 VDD.n45 6.3005
R620 VDD.n47 VDD.n46 6.3005
R621 VDD.n39 VDD.n19 6.3005
R622 VDD.n19 VDD.n18 6.3005
R623 VDD.n38 VDD.n37 6.3005
R624 VDD.n37 VDD.n36 6.3005
R625 VDD.n29 VDD.n21 6.3005
R626 VDD.n22 VDD.n21 6.3005
R627 VDD.n31 VDD.n30 6.3005
R628 VDD.n32 VDD.n31 6.3005
R629 VDD.n28 VDD.n25 6.3005
R630 VDD.n25 VDD.n24 6.3005
R631 VDD.n152 VDD.n151 5.54261
R632 VDD.n109 VDD.n107 5.51014
R633 VDD.n113 VDD.n111 5.51014
R634 VDD.n126 VDD.n124 5.51014
R635 VDD.n104 VDD.n102 5.51014
R636 VDD.n136 VDD.n134 5.51014
R637 VDD.n89 VDD.n87 5.51014
R638 VDD.n93 VDD.n91 5.51014
R639 VDD.n159 VDD.n157 5.51014
R640 VDD.n174 VDD.n172 5.51014
R641 VDD.n182 VDD.n180 5.51014
R642 VDD.n192 VDD.n190 5.51014
R643 VDD.n109 VDD.n108 5.32067
R644 VDD.n117 VDD.n116 5.32067
R645 VDD.n115 VDD.n114 5.32067
R646 VDD.n113 VDD.n112 5.32067
R647 VDD.n123 VDD.n122 5.32067
R648 VDD.n128 VDD.n127 5.32067
R649 VDD.n126 VDD.n125 5.32067
R650 VDD.n104 VDD.n103 5.32067
R651 VDD.n145 VDD.n144 5.32067
R652 VDD.n147 VDD.n146 5.32067
R653 VDD.n149 VDD.n148 5.32067
R654 VDD.n151 VDD.n150 5.32067
R655 VDD.n140 VDD.n139 5.32067
R656 VDD.n138 VDD.n137 5.32067
R657 VDD.n136 VDD.n135 5.32067
R658 VDD.n89 VDD.n88 5.32067
R659 VDD.n97 VDD.n96 5.32067
R660 VDD.n95 VDD.n94 5.32067
R661 VDD.n93 VDD.n92 5.32067
R662 VDD.n163 VDD.n162 5.32067
R663 VDD.n161 VDD.n160 5.32067
R664 VDD.n159 VDD.n158 5.32067
R665 VDD.n171 VDD.n170 5.32067
R666 VDD.n176 VDD.n175 5.32067
R667 VDD.n174 VDD.n173 5.32067
R668 VDD.n186 VDD.n185 5.32067
R669 VDD.n184 VDD.n183 5.32067
R670 VDD.n182 VDD.n181 5.32067
R671 VDD.n192 VDD.n191 5.32067
R672 VDD.n194 VDD.n193 5.28208
R673 VDD.n143 VDD.n142 5.08746
R674 VDD.n165 VDD.n99 5.08746
R675 VDD.n105 VDD.n104 5.02155
R676 VDD.n145 VDD.n143 4.68997
R677 VDD.n90 VDD.n89 4.54787
R678 VDD.n142 VDD.n141 4.5005
R679 VDD.n165 VDD.n164 4.5005
R680 VDD.n99 VDD.n98 4.5005
R681 VDD.n155 VDD.n153 3.26892
R682 VDD.n152 VDD.n105 1.95702
R683 VDD.n153 VDD.n100 1.8005
R684 VDD.n169 VDD.n168 1.61103
R685 VDD.n193 VDD.n189 1.51629
R686 VDD.n168 VDD.n166 1.42155
R687 VDD.n121 VDD.n120 1.42155
R688 VDD.n69 VDD.n68 1.26366
R689 VDD.n68 VDD.n9 1.26366
R690 VDD.n42 VDD.n9 1.26366
R691 VDD.n42 VDD.n41 1.26366
R692 VDD.n41 VDD.n20 1.26366
R693 VDD.n179 VDD.n178 1.23208
R694 VDD.n69 VDD.n0 1.21103
R695 VDD.n132 VDD.n130 1.13734
R696 VDD.n156 VDD.n155 1.08997
R697 VDD.n83 VDD.n2 1.0005
R698 VDD.n77 VDD.n2 1.0005
R699 VDD.n77 VDD.n5 1.0005
R700 VDD.n73 VDD.n5 1.0005
R701 VDD.n73 VDD.n7 1.0005
R702 VDD.n63 VDD.n7 1.0005
R703 VDD.n63 VDD.n11 1.0005
R704 VDD.n59 VDD.n11 1.0005
R705 VDD.n59 VDD.n13 1.0005
R706 VDD.n51 VDD.n13 1.0005
R707 VDD.n51 VDD.n16 1.0005
R708 VDD.n47 VDD.n16 1.0005
R709 VDD.n47 VDD.n18 1.0005
R710 VDD.n36 VDD.n18 1.0005
R711 VDD.n36 VDD.n22 1.0005
R712 VDD.n32 VDD.n22 1.0005
R713 VDD.n32 VDD.n24 1.0005
R714 VDD.n133 VDD.n132 0.947868
R715 VDD.n156 VDD.n85 0.568921
R716 VDD.n24 VDD.n23 0.481712
R717 VDD.n133 VDD.n100 0.474184
R718 VDD.n76 VDD.n1 0.444944
R719 VDD.n76 VDD.n75 0.444944
R720 VDD.n75 VDD.n74 0.444944
R721 VDD.n74 VDD.n6 0.444944
R722 VDD.n62 VDD.n6 0.444944
R723 VDD.n62 VDD.n61 0.444944
R724 VDD.n61 VDD.n60 0.444944
R725 VDD.n60 VDD.n12 0.444944
R726 VDD.n50 VDD.n12 0.444944
R727 VDD.n50 VDD.n49 0.444944
R728 VDD.n49 VDD.n48 0.444944
R729 VDD.n48 VDD.n17 0.444944
R730 VDD.n35 VDD.n17 0.444944
R731 VDD.n35 VDD.n34 0.444944
R732 VDD.n34 VDD.n33 0.444944
R733 VDD.n166 VDD.n85 0.379447
R734 VDD.n108 VDD.t19 0.228
R735 VDD.n108 VDD.t163 0.228
R736 VDD.n107 VDD.t113 0.228
R737 VDD.n107 VDD.t161 0.228
R738 VDD.n118 VDD.t12 0.228
R739 VDD.n118 VDD.t10 0.228
R740 VDD.n116 VDD.t107 0.228
R741 VDD.n116 VDD.t109 0.228
R742 VDD.n114 VDD.t103 0.228
R743 VDD.n114 VDD.t105 0.228
R744 VDD.n112 VDD.t102 0.228
R745 VDD.n112 VDD.t100 0.228
R746 VDD.n111 VDD.t97 0.228
R747 VDD.n111 VDD.t99 0.228
R748 VDD.n122 VDD.t71 0.228
R749 VDD.n122 VDD.t77 0.228
R750 VDD.n127 VDD.t73 0.228
R751 VDD.n127 VDD.t75 0.228
R752 VDD.n125 VDD.t65 0.228
R753 VDD.n125 VDD.t63 0.228
R754 VDD.n124 VDD.t69 0.228
R755 VDD.n124 VDD.t67 0.228
R756 VDD.n131 VDD.t123 0.228
R757 VDD.n131 VDD.t122 0.228
R758 VDD.n106 VDD.t3 0.228
R759 VDD.n106 VDD.t1 0.228
R760 VDD.n101 VDD.t117 0.228
R761 VDD.n101 VDD.t115 0.228
R762 VDD.n102 VDD.t159 0.228
R763 VDD.n102 VDD.t23 0.228
R764 VDD.n103 VDD.t21 0.228
R765 VDD.n103 VDD.t79 0.228
R766 VDD.n144 VDD.t44 0.228
R767 VDD.n144 VDD.t55 0.228
R768 VDD.n146 VDD.t51 0.228
R769 VDD.n146 VDD.t53 0.228
R770 VDD.n148 VDD.t50 0.228
R771 VDD.n148 VDD.t45 0.228
R772 VDD.n150 VDD.t48 0.228
R773 VDD.n150 VDD.t41 0.228
R774 VDD.n139 VDD.t60 0.228
R775 VDD.n139 VDD.t61 0.228
R776 VDD.n137 VDD.t58 0.228
R777 VDD.n137 VDD.t59 0.228
R778 VDD.n135 VDD.t57 0.228
R779 VDD.n135 VDD.t42 0.228
R780 VDD.n134 VDD.t47 0.228
R781 VDD.n134 VDD.t56 0.228
R782 VDD.n154 VDD.t129 0.228
R783 VDD.n154 VDD.t127 0.228
R784 VDD.n86 VDD.t170 0.228
R785 VDD.n86 VDD.t121 0.228
R786 VDD.n88 VDD.t134 0.228
R787 VDD.n88 VDD.t125 0.228
R788 VDD.n87 VDD.t8 0.228
R789 VDD.n87 VDD.t132 0.228
R790 VDD.n96 VDD.t156 0.228
R791 VDD.n96 VDD.t157 0.228
R792 VDD.n94 VDD.t154 0.228
R793 VDD.n94 VDD.t155 0.228
R794 VDD.n92 VDD.t152 0.228
R795 VDD.n92 VDD.t153 0.228
R796 VDD.n91 VDD.t136 0.228
R797 VDD.n91 VDD.t151 0.228
R798 VDD.n162 VDD.t148 0.228
R799 VDD.n162 VDD.t150 0.228
R800 VDD.n160 VDD.t144 0.228
R801 VDD.n160 VDD.t146 0.228
R802 VDD.n158 VDD.t141 0.228
R803 VDD.n158 VDD.t143 0.228
R804 VDD.n157 VDD.t137 0.228
R805 VDD.n157 VDD.t139 0.228
R806 VDD.n167 VDD.t16 0.228
R807 VDD.n167 VDD.t14 0.228
R808 VDD.n170 VDD.t83 0.228
R809 VDD.n170 VDD.t95 0.228
R810 VDD.n175 VDD.t89 0.228
R811 VDD.n175 VDD.t93 0.228
R812 VDD.n173 VDD.t87 0.228
R813 VDD.n173 VDD.t91 0.228
R814 VDD.n172 VDD.t85 0.228
R815 VDD.n172 VDD.t81 0.228
R816 VDD.n187 VDD.t111 0.228
R817 VDD.n187 VDD.t171 0.228
R818 VDD.n185 VDD.t37 0.228
R819 VDD.n185 VDD.t39 0.228
R820 VDD.n183 VDD.t31 0.228
R821 VDD.n183 VDD.t35 0.228
R822 VDD.n181 VDD.t29 0.228
R823 VDD.n181 VDD.t33 0.228
R824 VDD.n180 VDD.t25 0.228
R825 VDD.n180 VDD.t27 0.228
R826 VDD.n191 VDD.t119 0.228
R827 VDD.n191 VDD.t167 0.228
R828 VDD.n190 VDD.t165 0.228
R829 VDD.n190 VDD.t169 0.228
R830 VDD.n115 VDD.n113 0.189974
R831 VDD.n117 VDD.n115 0.189974
R832 VDD.n128 VDD.n126 0.189974
R833 VDD.n138 VDD.n136 0.189974
R834 VDD.n140 VDD.n138 0.189974
R835 VDD.n141 VDD.n140 0.189974
R836 VDD.n151 VDD.n149 0.189974
R837 VDD.n149 VDD.n147 0.189974
R838 VDD.n147 VDD.n145 0.189974
R839 VDD.n161 VDD.n159 0.189974
R840 VDD.n163 VDD.n161 0.189974
R841 VDD.n164 VDD.n163 0.189974
R842 VDD.n95 VDD.n93 0.189974
R843 VDD.n97 VDD.n95 0.189974
R844 VDD.n98 VDD.n97 0.189974
R845 VDD.n176 VDD.n174 0.189974
R846 VDD.n184 VDD.n182 0.189974
R847 VDD.n186 VDD.n184 0.189974
R848 VDD.n194 VDD.n84 0.146816
R849 VDD.n84 VDD.n1 0.133833
R850 VDD VDD.n0 0.109447
R851 VDD.n189 VDD.n179 0.0952368
R852 VDD.n178 VDD.n169 0.0952368
R853 VDD.n130 VDD.n121 0.0952368
R854 VDD.n120 VDD.n110 0.0952368
R855 VDD.n129 VDD.n128 0.0952368
R856 VDD.n129 VDD.n123 0.0952368
R857 VDD.n177 VDD.n176 0.0952368
R858 VDD.n177 VDD.n171 0.0952368
R859 VDD VDD.n194 0.0205
R860 VSS.n104 VSS.n80 524.194
R861 VSS.n124 VSS.n3 524.194
R862 VSS.n130 VSS.n3 524.194
R863 VSS.n43 VSS.n42 524.194
R864 VSS.n70 VSS.t6 398.387
R865 VSS.n63 VSS.t86 398.387
R866 VSS.n110 VSS.t84 377.42
R867 VSS.n49 VSS.t69 377.42
R868 VSS.t125 VSS.t127 335.485
R869 VSS.t94 VSS.t112 335.485
R870 VSS.n112 VSS.t115 272.582
R871 VSS.n56 VSS.t92 272.582
R872 VSS.n111 VSS.t33 251.613
R873 VSS.t47 VSS.n111 251.613
R874 VSS.n50 VSS.t41 251.613
R875 VSS.n50 VSS.t53 251.613
R876 VSS.n104 VSS.n103 241.13
R877 VSS.n43 VSS.n22 241.13
R878 VSS.t23 VSS.n70 167.743
R879 VSS.n63 VSS.t62 167.743
R880 VSS.t27 VSS.n110 146.774
R881 VSS.n112 VSS.t43 146.774
R882 VSS.n56 VSS.t35 146.774
R883 VSS.t57 VSS.n49 146.774
R884 VSS.t136 VSS.t71 125.806
R885 VSS.t82 VSS.t90 125.806
R886 VSS.n35 VSS.n24 87.5005
R887 VSS.n31 VSS.n29 87.5005
R888 VSS.n29 VSS.n28 87.5005
R889 VSS.n90 VSS.n81 87.5005
R890 VSS.n90 VSS.n76 87.5005
R891 VSS.n76 VSS.n75 87.5005
R892 VSS.n75 VSS.n74 87.5005
R893 VSS.n74 VSS.n69 87.5005
R894 VSS.n119 VSS.n69 87.5005
R895 VSS.n119 VSS.n10 87.5005
R896 VSS.n123 VSS.n10 87.5005
R897 VSS.n123 VSS.n9 87.5005
R898 VSS.n9 VSS.n2 87.5005
R899 VSS.n64 VSS.n2 87.5005
R900 VSS.n64 VSS.n12 87.5005
R901 VSS.n55 VSS.n12 87.5005
R902 VSS.n55 VSS.n16 87.5005
R903 VSS.n51 VSS.n16 87.5005
R904 VSS.n51 VSS.n18 87.5005
R905 VSS.n41 VSS.n18 87.5005
R906 VSS.n41 VSS.n38 87.5005
R907 VSS.n97 VSS.n96 87.5005
R908 VSS.n101 VSS.n85 87.5005
R909 VSS.n105 VSS.n77 87.5005
R910 VSS.n109 VSS.n77 87.5005
R911 VSS.n109 VSS.n73 87.5005
R912 VSS.n113 VSS.n73 87.5005
R913 VSS.n113 VSS.n71 87.5005
R914 VSS.n117 VSS.n71 87.5005
R915 VSS.n117 VSS.n8 87.5005
R916 VSS.n125 VSS.n8 87.5005
R917 VSS.n125 VSS.n5 87.5005
R918 VSS.n129 VSS.n5 87.5005
R919 VSS.n129 VSS.n4 87.5005
R920 VSS.n61 VSS.n4 87.5005
R921 VSS.n61 VSS.n13 87.5005
R922 VSS.n57 VSS.n13 87.5005
R923 VSS.n57 VSS.n15 87.5005
R924 VSS.n48 VSS.n15 87.5005
R925 VSS.n48 VSS.n19 87.5005
R926 VSS.n44 VSS.n19 87.5005
R927 VSS.n124 VSS.t4 83.8715
R928 VSS.t88 VSS.n130 83.8715
R929 VSS.n38 VSS.n37 68.2505
R930 VSS.n93 VSS.n81 68.2505
R931 VSS.n80 VSS.t73 62.9037
R932 VSS.n42 VSS.t18 62.9037
R933 VSS.n105 VSS.n79 50.7505
R934 VSS.n44 VSS.n21 50.7505
R935 VSS.n84 VSS.n79 43.7505
R936 VSS.t73 VSS.t75 41.936
R937 VSS.t75 VSS.t84 41.936
R938 VSS.t29 VSS.t27 41.936
R939 VSS.t31 VSS.t29 41.936
R940 VSS.t33 VSS.t31 41.936
R941 VSS.t49 VSS.t47 41.936
R942 VSS.t45 VSS.t49 41.936
R943 VSS.t43 VSS.t45 41.936
R944 VSS.t115 VSS.t118 41.936
R945 VSS.t118 VSS.t80 41.936
R946 VSS.t80 VSS.t1 41.936
R947 VSS.t1 VSS.t0 41.936
R948 VSS.t0 VSS.t17 41.936
R949 VSS.t17 VSS.t123 41.936
R950 VSS.t123 VSS.t125 41.936
R951 VSS.t127 VSS.t129 41.936
R952 VSS.t129 VSS.t77 41.936
R953 VSS.t77 VSS.t59 41.936
R954 VSS.t79 VSS.t78 41.936
R955 VSS.t78 VSS.t133 41.936
R956 VSS.t133 VSS.t136 41.936
R957 VSS.t71 VSS.t21 41.936
R958 VSS.t21 VSS.t23 41.936
R959 VSS.t62 VSS.t2 41.936
R960 VSS.t2 VSS.t82 41.936
R961 VSS.t90 VSS.t105 41.936
R962 VSS.t105 VSS.t14 41.936
R963 VSS.t14 VSS.t10 41.936
R964 VSS.t16 VSS.t8 41.936
R965 VSS.t110 VSS.t16 41.936
R966 VSS.t112 VSS.t110 41.936
R967 VSS.t96 VSS.t94 41.936
R968 VSS.t20 VSS.t96 41.936
R969 VSS.t26 VSS.t20 41.936
R970 VSS.t25 VSS.t26 41.936
R971 VSS.t15 VSS.t25 41.936
R972 VSS.t102 VSS.t15 41.936
R973 VSS.t92 VSS.t102 41.936
R974 VSS.t37 VSS.t35 41.936
R975 VSS.t39 VSS.t37 41.936
R976 VSS.t41 VSS.t39 41.936
R977 VSS.t53 VSS.t55 41.936
R978 VSS.t55 VSS.t51 41.936
R979 VSS.t51 VSS.t57 41.936
R980 VSS.t138 VSS.t69 41.936
R981 VSS.t18 VSS.t138 41.936
R982 VSS.n132 VSS.n1 29.6637
R983 VSS.n132 VSS.n131 28.4005
R984 VSS.n173 VSS.n172 24.6095
R985 VSS.n171 VSS.n170 24.6095
R986 VSS.n118 VSS.t59 20.9682
R987 VSS.n118 VSS.t79 20.9682
R988 VSS.t6 VSS.n1 20.9682
R989 VSS.t4 VSS.n1 20.9682
R990 VSS.n131 VSS.t88 20.9682
R991 VSS.n131 VSS.t86 20.9682
R992 VSS.t10 VSS.n62 20.9682
R993 VSS.n62 VSS.t8 20.9682
R994 VSS.n140 VSS.n134 19.9694
R995 VSS VSS.n0 19.2568
R996 VSS.n211 VSS.n210 18.5483
R997 VSS.n164 VSS.n163 15.2627
R998 VSS.n202 VSS.n201 15.2222
R999 VSS.n144 VSS.n143 15.2222
R1000 VSS.n207 VSS.n203 13.793
R1001 VSS.n139 VSS.n135 13.793
R1002 VSS.n198 VSS.n197 13.2657
R1003 VSS.n155 VSS.n154 13.2657
R1004 VSS.n191 VSS.n190 12.9149
R1005 VSS.n148 VSS.n147 12.9149
R1006 VSS.n168 VSS.n158 12.4151
R1007 VSS.n187 VSS.n186 11.0126
R1008 VSS.n208 VSS.n207 10.7222
R1009 VSS.n140 VSS.n139 10.7222
R1010 VSS.n178 VSS.n177 9.98011
R1011 VSS.n191 VSS.n188 8.76572
R1012 VSS.n148 VSS.n145 8.76572
R1013 VSS.n178 VSS.n176 7.51148
R1014 VSS.n179 VSS.n174 6.41789
R1015 VSS.n164 VSS.n156 6.41789
R1016 VSS.n169 VSS.n168 6.41789
R1017 VSS.n158 VSS.t24 5.7796
R1018 VSS.n210 VSS.t19 5.63749
R1019 VSS.n134 VSS.t85 5.63749
R1020 VSS.n176 VSS.t83 5.59012
R1021 VSS.n194 VSS.n192 5.57485
R1022 VSS.n176 VSS.n175 5.57485
R1023 VSS.n182 VSS.n180 5.57485
R1024 VSS.n201 VSS.n200 5.57485
R1025 VSS.n206 VSS.n205 5.57485
R1026 VSS.n151 VSS.n149 5.57485
R1027 VSS.n162 VSS.n160 5.57485
R1028 VSS.n143 VSS.n142 5.57485
R1029 VSS.n138 VSS.n137 5.57485
R1030 VSS.n210 VSS.n209 5.52748
R1031 VSS.n134 VSS.n133 5.52748
R1032 VSS.n197 VSS.n189 5.38537
R1033 VSS.n196 VSS.n195 5.38537
R1034 VSS.n194 VSS.n193 5.38537
R1035 VSS.n186 VSS.n185 5.38537
R1036 VSS.n184 VSS.n183 5.38537
R1037 VSS.n182 VSS.n181 5.38537
R1038 VSS.n201 VSS.n199 5.38537
R1039 VSS.n206 VSS.n204 5.38537
R1040 VSS.n154 VSS.n146 5.38537
R1041 VSS.n153 VSS.n152 5.38537
R1042 VSS.n151 VSS.n150 5.38537
R1043 VSS.n167 VSS.n166 5.38537
R1044 VSS.n158 VSS.n157 5.38537
R1045 VSS.n165 VSS.n159 5.38537
R1046 VSS.n162 VSS.n161 5.38537
R1047 VSS.n143 VSS.n141 5.38537
R1048 VSS.n138 VSS.n136 5.38537
R1049 VSS.n179 VSS.n178 5.28311
R1050 VSS.n105 VSS.n104 5.2005
R1051 VSS.n106 VSS.n105 5.2005
R1052 VSS.n80 VSS.n77 5.2005
R1053 VSS.n107 VSS.n77 5.2005
R1054 VSS.n110 VSS.n109 5.2005
R1055 VSS.n109 VSS.n108 5.2005
R1056 VSS.n111 VSS.n73 5.2005
R1057 VSS.n73 VSS.n72 5.2005
R1058 VSS.n113 VSS.n112 5.2005
R1059 VSS.n114 VSS.n113 5.2005
R1060 VSS.t123 VSS.n71 5.2005
R1061 VSS.n115 VSS.n71 5.2005
R1062 VSS.n118 VSS.n117 5.2005
R1063 VSS.n117 VSS.n116 5.2005
R1064 VSS.n70 VSS.n8 5.2005
R1065 VSS.n8 VSS.n7 5.2005
R1066 VSS.n125 VSS.n124 5.2005
R1067 VSS.n126 VSS.n125 5.2005
R1068 VSS.n5 VSS.n3 5.2005
R1069 VSS.n127 VSS.n5 5.2005
R1070 VSS.n130 VSS.n129 5.2005
R1071 VSS.n129 VSS.n128 5.2005
R1072 VSS.n63 VSS.n4 5.2005
R1073 VSS.n6 VSS.n4 5.2005
R1074 VSS.n62 VSS.n61 5.2005
R1075 VSS.n61 VSS.n60 5.2005
R1076 VSS.t96 VSS.n13 5.2005
R1077 VSS.n59 VSS.n13 5.2005
R1078 VSS.n57 VSS.n56 5.2005
R1079 VSS.n58 VSS.n57 5.2005
R1080 VSS.n50 VSS.n15 5.2005
R1081 VSS.n15 VSS.n14 5.2005
R1082 VSS.n49 VSS.n48 5.2005
R1083 VSS.n48 VSS.n47 5.2005
R1084 VSS.n42 VSS.n19 5.2005
R1085 VSS.n46 VSS.n19 5.2005
R1086 VSS.n44 VSS.n43 5.2005
R1087 VSS.n45 VSS.n44 5.2005
R1088 VSS.n43 VSS.n38 5.2005
R1089 VSS.n39 VSS.n38 5.2005
R1090 VSS.n42 VSS.n41 5.2005
R1091 VSS.n41 VSS.n40 5.2005
R1092 VSS.n49 VSS.n18 5.2005
R1093 VSS.n18 VSS.n17 5.2005
R1094 VSS.n51 VSS.n50 5.2005
R1095 VSS.n52 VSS.n51 5.2005
R1096 VSS.n56 VSS.n16 5.2005
R1097 VSS.n53 VSS.n16 5.2005
R1098 VSS.t96 VSS.n55 5.2005
R1099 VSS.n55 VSS.n54 5.2005
R1100 VSS.n62 VSS.n12 5.2005
R1101 VSS.n12 VSS.n11 5.2005
R1102 VSS.n64 VSS.n63 5.2005
R1103 VSS.n65 VSS.n64 5.2005
R1104 VSS.n130 VSS.n2 5.2005
R1105 VSS.n66 VSS.n2 5.2005
R1106 VSS.n9 VSS.n3 5.2005
R1107 VSS.n67 VSS.n9 5.2005
R1108 VSS.n124 VSS.n123 5.2005
R1109 VSS.n123 VSS.n122 5.2005
R1110 VSS.n70 VSS.n10 5.2005
R1111 VSS.n121 VSS.n10 5.2005
R1112 VSS.n119 VSS.n118 5.2005
R1113 VSS.n120 VSS.n119 5.2005
R1114 VSS.t123 VSS.n69 5.2005
R1115 VSS.n69 VSS.n68 5.2005
R1116 VSS.n112 VSS.n74 5.2005
R1117 VSS.n87 VSS.n74 5.2005
R1118 VSS.n111 VSS.n75 5.2005
R1119 VSS.n88 VSS.n75 5.2005
R1120 VSS.n110 VSS.n76 5.2005
R1121 VSS.n89 VSS.n76 5.2005
R1122 VSS.n90 VSS.n80 5.2005
R1123 VSS.n91 VSS.n90 5.2005
R1124 VSS.n104 VSS.n81 5.2005
R1125 VSS.n92 VSS.n81 5.2005
R1126 VSS.n103 VSS.n79 5.2005
R1127 VSS.n79 VSS.n78 5.2005
R1128 VSS.n86 VSS.n84 5.2005
R1129 VSS.n101 VSS.n100 5.2005
R1130 VSS.n99 VSS.n85 5.2005
R1131 VSS.n98 VSS.n97 5.2005
R1132 VSS.n96 VSS.n95 5.2005
R1133 VSS.n94 VSS.n93 5.2005
R1134 VSS.n37 VSS.n23 5.2005
R1135 VSS.n35 VSS.n34 5.2005
R1136 VSS.n33 VSS.n24 5.2005
R1137 VSS.n32 VSS.n31 5.2005
R1138 VSS.n29 VSS.n22 5.2005
R1139 VSS.n29 VSS.n25 5.2005
R1140 VSS.n28 VSS.n26 5.2005
R1141 VSS.n21 VSS.n20 5.2005
R1142 VSS.n212 VSS.n211 4.99787
R1143 VSS.n102 VSS.n84 4.6486
R1144 VSS.n85 VSS.n83 4.6486
R1145 VSS.n96 VSS.n82 4.6486
R1146 VSS.n37 VSS.n36 4.6486
R1147 VSS.n30 VSS.n24 4.6486
R1148 VSS.n36 VSS.n35 4.6486
R1149 VSS.n31 VSS.n30 4.6486
R1150 VSS.n93 VSS.n82 4.6486
R1151 VSS.n97 VSS.n83 4.6486
R1152 VSS.n102 VSS.n101 4.6486
R1153 VSS.n168 VSS.n167 4.59524
R1154 VSS.n196 VSS.n191 4.5005
R1155 VSS.n184 VSS.n179 4.5005
R1156 VSS.n207 VSS.n206 4.5005
R1157 VSS.n153 VSS.n148 4.5005
R1158 VSS.n165 VSS.n164 4.5005
R1159 VSS.n139 VSS.n138 4.5005
R1160 VSS.n212 VSS.n132 4.39261
R1161 VSS.n28 VSS.n27 4.20229
R1162 VSS.n27 VSS.n21 4.20229
R1163 VSS.n173 VSS.n171 2.84261
R1164 VSS.n174 VSS.n173 2.03734
R1165 VSS.n171 VSS.n169 1.94261
R1166 VSS.n144 VSS.n140 1.42155
R1167 VSS.n145 VSS.n144 1.42155
R1168 VSS.n208 VSS.n202 1.42155
R1169 VSS.n211 VSS.n208 1.42155
R1170 VSS.n156 VSS.n155 1.23208
R1171 VSS.n202 VSS.n198 1.23208
R1172 VSS.n188 VSS.n187 1.13734
R1173 VSS.n34 VSS.n23 1.1255
R1174 VSS.n34 VSS.n33 1.1255
R1175 VSS.n33 VSS.n32 1.1255
R1176 VSS.n32 VSS.n25 1.1255
R1177 VSS.n26 VSS.n25 1.1255
R1178 VSS.n92 VSS.n91 1.1255
R1179 VSS.n91 VSS.n89 1.1255
R1180 VSS.n89 VSS.n88 1.1255
R1181 VSS.n88 VSS.n87 1.1255
R1182 VSS.n87 VSS.n68 1.1255
R1183 VSS.n120 VSS.n68 1.1255
R1184 VSS.n121 VSS.n120 1.1255
R1185 VSS.n122 VSS.n121 1.1255
R1186 VSS.n122 VSS.n67 1.1255
R1187 VSS.n67 VSS.n66 1.1255
R1188 VSS.n66 VSS.n65 1.1255
R1189 VSS.n65 VSS.n11 1.1255
R1190 VSS.n54 VSS.n11 1.1255
R1191 VSS.n54 VSS.n53 1.1255
R1192 VSS.n53 VSS.n52 1.1255
R1193 VSS.n52 VSS.n17 1.1255
R1194 VSS.n40 VSS.n17 1.1255
R1195 VSS.n40 VSS.n39 1.1255
R1196 VSS.n95 VSS.n94 1.1255
R1197 VSS.n98 VSS.n95 1.1255
R1198 VSS.n99 VSS.n98 1.1255
R1199 VSS.n100 VSS.n99 1.1255
R1200 VSS.n100 VSS.n86 1.1255
R1201 VSS.n107 VSS.n106 1.1255
R1202 VSS.n108 VSS.n107 1.1255
R1203 VSS.n108 VSS.n72 1.1255
R1204 VSS.n114 VSS.n72 1.1255
R1205 VSS.n115 VSS.n114 1.1255
R1206 VSS.n116 VSS.n115 1.1255
R1207 VSS.n116 VSS.n7 1.1255
R1208 VSS.n126 VSS.n7 1.1255
R1209 VSS.n127 VSS.n126 1.1255
R1210 VSS.n128 VSS.n127 1.1255
R1211 VSS.n128 VSS.n6 1.1255
R1212 VSS.n60 VSS.n6 1.1255
R1213 VSS.n60 VSS.n59 1.1255
R1214 VSS.n59 VSS.n58 1.1255
R1215 VSS.n58 VSS.n14 1.1255
R1216 VSS.n47 VSS.n14 1.1255
R1217 VSS.n47 VSS.n46 1.1255
R1218 VSS.n46 VSS.n45 1.1255
R1219 VSS.n94 VSS.n92 0.878
R1220 VSS.n106 VSS.n78 0.653
R1221 VSS.n45 VSS.n20 0.653
R1222 VSS.n26 VSS.n20 0.563
R1223 VSS.n86 VSS.n78 0.563
R1224 VSS.n39 VSS.n0 0.518
R1225 VSS.n27 VSS.n22 0.500354
R1226 VSS.n203 VSS.t67 0.41
R1227 VSS.n203 VSS.t66 0.41
R1228 VSS.n172 VSS.t89 0.41
R1229 VSS.n172 VSS.t87 0.41
R1230 VSS.n170 VSS.t7 0.41
R1231 VSS.n170 VSS.t5 0.41
R1232 VSS.n135 VSS.t68 0.41
R1233 VSS.n135 VSS.t61 0.41
R1234 VSS.n23 VSS.n0 0.3605
R1235 VSS.n169 VSS.n156 0.284711
R1236 VSS.n187 VSS.n174 0.284711
R1237 VSS.n103 VSS.n102 0.2772
R1238 VSS.n103 VSS.n83 0.2772
R1239 VSS.n103 VSS.n82 0.2772
R1240 VSS.n36 VSS.n22 0.2772
R1241 VSS.n30 VSS.n22 0.2772
R1242 VSS.n209 VSS.t70 0.20525
R1243 VSS.n209 VSS.t139 0.20525
R1244 VSS.n189 VSS.t103 0.20525
R1245 VSS.n189 VSS.t93 0.20525
R1246 VSS.n190 VSS.t65 0.20525
R1247 VSS.n190 VSS.t64 0.20525
R1248 VSS.n195 VSS.t100 0.20525
R1249 VSS.n195 VSS.t101 0.20525
R1250 VSS.n193 VSS.t98 0.20525
R1251 VSS.n193 VSS.t99 0.20525
R1252 VSS.n192 VSS.t95 0.20525
R1253 VSS.n192 VSS.t97 0.20525
R1254 VSS.n185 VSS.t111 0.20525
R1255 VSS.n185 VSS.t113 0.20525
R1256 VSS.n177 VSS.t11 0.20525
R1257 VSS.n177 VSS.t9 0.20525
R1258 VSS.n175 VSS.t63 0.20525
R1259 VSS.n175 VSS.t3 0.20525
R1260 VSS.n183 VSS.t108 0.20525
R1261 VSS.n183 VSS.t109 0.20525
R1262 VSS.n181 VSS.t107 0.20525
R1263 VSS.n181 VSS.t104 0.20525
R1264 VSS.n180 VSS.t91 0.20525
R1265 VSS.n180 VSS.t106 0.20525
R1266 VSS.n199 VSS.t40 0.20525
R1267 VSS.n199 VSS.t42 0.20525
R1268 VSS.n200 VSS.t36 0.20525
R1269 VSS.n200 VSS.t38 0.20525
R1270 VSS.n204 VSS.t52 0.20525
R1271 VSS.n204 VSS.t58 0.20525
R1272 VSS.n205 VSS.t54 0.20525
R1273 VSS.n205 VSS.t56 0.20525
R1274 VSS.n146 VSS.t124 0.20525
R1275 VSS.n146 VSS.t126 0.20525
R1276 VSS.n147 VSS.t13 0.20525
R1277 VSS.n147 VSS.t12 0.20525
R1278 VSS.n152 VSS.t114 0.20525
R1279 VSS.n152 VSS.t121 0.20525
R1280 VSS.n150 VSS.t120 0.20525
R1281 VSS.n150 VSS.t117 0.20525
R1282 VSS.n149 VSS.t116 0.20525
R1283 VSS.n149 VSS.t119 0.20525
R1284 VSS.n163 VSS.t60 0.20525
R1285 VSS.n163 VSS.t81 0.20525
R1286 VSS.n166 VSS.t134 0.20525
R1287 VSS.n166 VSS.t137 0.20525
R1288 VSS.n157 VSS.t72 0.20525
R1289 VSS.n157 VSS.t22 0.20525
R1290 VSS.n159 VSS.t132 0.20525
R1291 VSS.n159 VSS.t135 0.20525
R1292 VSS.n161 VSS.t122 0.20525
R1293 VSS.n161 VSS.t131 0.20525
R1294 VSS.n160 VSS.t128 0.20525
R1295 VSS.n160 VSS.t130 0.20525
R1296 VSS.n141 VSS.t46 0.20525
R1297 VSS.n141 VSS.t44 0.20525
R1298 VSS.n142 VSS.t48 0.20525
R1299 VSS.n142 VSS.t50 0.20525
R1300 VSS.n133 VSS.t74 0.20525
R1301 VSS.n133 VSS.t76 0.20525
R1302 VSS.n136 VSS.t32 0.20525
R1303 VSS.n136 VSS.t34 0.20525
R1304 VSS.n137 VSS.t28 0.20525
R1305 VSS.n137 VSS.t30 0.20525
R1306 VSS.n155 VSS.n145 0.189974
R1307 VSS.n198 VSS.n188 0.189974
R1308 VSS.n196 VSS.n194 0.189974
R1309 VSS.n197 VSS.n196 0.189974
R1310 VSS.n184 VSS.n182 0.189974
R1311 VSS.n186 VSS.n184 0.189974
R1312 VSS.n153 VSS.n151 0.189974
R1313 VSS.n154 VSS.n153 0.189974
R1314 VSS.n165 VSS.n162 0.189974
R1315 VSS.n167 VSS.n165 0.189974
R1316 VSS VSS.n212 0.0205
R1317 O_RST_TAIL.n10 O_RST_TAIL.n2 15.9369
R1318 O_RST_TAIL.n10 O_RST_TAIL.n9 10.957
R1319 O_RST_TAIL.n4 O_RST_TAIL.t11 5.7796
R1320 O_RST_TAIL.n9 O_RST_TAIL.t4 5.68486
R1321 O_RST_TAIL.n2 O_RST_TAIL.n0 5.57485
R1322 O_RST_TAIL.n4 O_RST_TAIL.n3 5.38537
R1323 O_RST_TAIL.n2 O_RST_TAIL.n1 5.38537
R1324 O_RST_TAIL.n6 O_RST_TAIL.n5 5.38537
R1325 O_RST_TAIL.n8 O_RST_TAIL.n7 5.38537
R1326 O_RST_TAIL.n3 O_RST_TAIL.t9 0.20525
R1327 O_RST_TAIL.n3 O_RST_TAIL.t10 0.20525
R1328 O_RST_TAIL.n1 O_RST_TAIL.t2 0.20525
R1329 O_RST_TAIL.n1 O_RST_TAIL.t0 0.20525
R1330 O_RST_TAIL.n0 O_RST_TAIL.t1 0.20525
R1331 O_RST_TAIL.n0 O_RST_TAIL.t3 0.20525
R1332 O_RST_TAIL.n5 O_RST_TAIL.t7 0.20525
R1333 O_RST_TAIL.n5 O_RST_TAIL.t8 0.20525
R1334 O_RST_TAIL.n7 O_RST_TAIL.t5 0.20525
R1335 O_RST_TAIL.n7 O_RST_TAIL.t6 0.20525
R1336 O_RST_TAIL.n8 O_RST_TAIL.n6 0.189974
R1337 O_RST_TAIL.n6 O_RST_TAIL.n4 0.189974
R1338 O_RST_TAIL.n9 O_RST_TAIL.n8 0.0952368
R1339 O_RST_TAIL O_RST_TAIL.n10 0.0396304
R1340 E_RST_TAIL.n10 E_RST_TAIL.n9 11.9456
R1341 E_RST_TAIL.n10 E_RST_TAIL.n6 11.6614
R1342 E_RST_TAIL.n1 E_RST_TAIL.t11 5.7796
R1343 E_RST_TAIL.n6 E_RST_TAIL.t4 5.68486
R1344 E_RST_TAIL.n9 E_RST_TAIL.n7 5.57485
R1345 E_RST_TAIL.n1 E_RST_TAIL.n0 5.38537
R1346 E_RST_TAIL.n9 E_RST_TAIL.n8 5.38537
R1347 E_RST_TAIL.n3 E_RST_TAIL.n2 5.38537
R1348 E_RST_TAIL.n5 E_RST_TAIL.n4 5.38537
R1349 E_RST_TAIL.n0 E_RST_TAIL.t9 0.20525
R1350 E_RST_TAIL.n0 E_RST_TAIL.t10 0.20525
R1351 E_RST_TAIL.n8 E_RST_TAIL.t0 0.20525
R1352 E_RST_TAIL.n8 E_RST_TAIL.t2 0.20525
R1353 E_RST_TAIL.n7 E_RST_TAIL.t3 0.20525
R1354 E_RST_TAIL.n7 E_RST_TAIL.t1 0.20525
R1355 E_RST_TAIL.n2 E_RST_TAIL.t7 0.20525
R1356 E_RST_TAIL.n2 E_RST_TAIL.t8 0.20525
R1357 E_RST_TAIL.n4 E_RST_TAIL.t5 0.20525
R1358 E_RST_TAIL.n4 E_RST_TAIL.t6 0.20525
R1359 E_RST_TAIL.n5 E_RST_TAIL.n3 0.189974
R1360 E_RST_TAIL.n3 E_RST_TAIL.n1 0.189974
R1361 E_RST_TAIL.n6 E_RST_TAIL.n5 0.0952368
R1362 E_RST_TAIL E_RST_TAIL.n10 0.0396304
R1363 O_SET_TAIL.n9 O_SET_TAIL.n5 11.3875
R1364 O_SET_TAIL.n9 O_SET_TAIL.n8 9.68219
R1365 O_SET_TAIL.n1 O_SET_TAIL.t11 5.7796
R1366 O_SET_TAIL.n5 O_SET_TAIL.t4 5.7796
R1367 O_SET_TAIL.n8 O_SET_TAIL.n6 5.57485
R1368 O_SET_TAIL.n1 O_SET_TAIL.n0 5.38537
R1369 O_SET_TAIL.n3 O_SET_TAIL.n2 5.38537
R1370 O_SET_TAIL.n8 O_SET_TAIL.n7 5.38537
R1371 O_SET_TAIL.n5 O_SET_TAIL.n4 5.38537
R1372 O_SET_TAIL.n0 O_SET_TAIL.t9 0.20525
R1373 O_SET_TAIL.n0 O_SET_TAIL.t10 0.20525
R1374 O_SET_TAIL.n2 O_SET_TAIL.t7 0.20525
R1375 O_SET_TAIL.n2 O_SET_TAIL.t8 0.20525
R1376 O_SET_TAIL.n7 O_SET_TAIL.t3 0.20525
R1377 O_SET_TAIL.n7 O_SET_TAIL.t2 0.20525
R1378 O_SET_TAIL.n6 O_SET_TAIL.t1 0.20525
R1379 O_SET_TAIL.n6 O_SET_TAIL.t0 0.20525
R1380 O_SET_TAIL.n4 O_SET_TAIL.t5 0.20525
R1381 O_SET_TAIL.n4 O_SET_TAIL.t6 0.20525
R1382 O_SET_TAIL.n5 O_SET_TAIL.n3 0.189974
R1383 O_SET_TAIL.n3 O_SET_TAIL.n1 0.189974
R1384 O_SET_TAIL O_SET_TAIL.n9 0.0396304
R1385 E_SET_TAIL.n9 E_SET_TAIL.n2 12.1083
R1386 E_SET_TAIL.n9 E_SET_TAIL.n8 10.2135
R1387 E_SET_TAIL.n4 E_SET_TAIL.t11 5.7796
R1388 E_SET_TAIL.n8 E_SET_TAIL.t4 5.7796
R1389 E_SET_TAIL.n2 E_SET_TAIL.n0 5.57485
R1390 E_SET_TAIL.n4 E_SET_TAIL.n3 5.38537
R1391 E_SET_TAIL.n6 E_SET_TAIL.n5 5.38537
R1392 E_SET_TAIL.n2 E_SET_TAIL.n1 5.38537
R1393 E_SET_TAIL.n8 E_SET_TAIL.n7 5.38537
R1394 E_SET_TAIL.n3 E_SET_TAIL.t9 0.20525
R1395 E_SET_TAIL.n3 E_SET_TAIL.t10 0.20525
R1396 E_SET_TAIL.n5 E_SET_TAIL.t7 0.20525
R1397 E_SET_TAIL.n5 E_SET_TAIL.t8 0.20525
R1398 E_SET_TAIL.n1 E_SET_TAIL.t3 0.20525
R1399 E_SET_TAIL.n1 E_SET_TAIL.t2 0.20525
R1400 E_SET_TAIL.n0 E_SET_TAIL.t1 0.20525
R1401 E_SET_TAIL.n0 E_SET_TAIL.t0 0.20525
R1402 E_SET_TAIL.n7 E_SET_TAIL.t5 0.20525
R1403 E_SET_TAIL.n7 E_SET_TAIL.t6 0.20525
R1404 E_SET_TAIL.n8 E_SET_TAIL.n6 0.189974
R1405 E_SET_TAIL.n6 E_SET_TAIL.n4 0.189974
R1406 E_SET_TAIL E_SET_TAIL.n9 0.0396304
R1407 O_PSET_TAIL.n10 O_PSET_TAIL.n2 15.7351
R1408 O_PSET_TAIL.n10 O_PSET_TAIL.n9 12.6005
R1409 O_PSET_TAIL.n4 O_PSET_TAIL.t10 5.73764
R1410 O_PSET_TAIL.n9 O_PSET_TAIL.t3 5.54817
R1411 O_PSET_TAIL.n2 O_PSET_TAIL.n0 5.51014
R1412 O_PSET_TAIL.n4 O_PSET_TAIL.n3 5.32067
R1413 O_PSET_TAIL.n6 O_PSET_TAIL.n5 5.32067
R1414 O_PSET_TAIL.n8 O_PSET_TAIL.n7 5.32067
R1415 O_PSET_TAIL.n2 O_PSET_TAIL.n1 5.32067
R1416 O_PSET_TAIL.n3 O_PSET_TAIL.t8 0.228
R1417 O_PSET_TAIL.n3 O_PSET_TAIL.t9 0.228
R1418 O_PSET_TAIL.n5 O_PSET_TAIL.t6 0.228
R1419 O_PSET_TAIL.n5 O_PSET_TAIL.t7 0.228
R1420 O_PSET_TAIL.n7 O_PSET_TAIL.t4 0.228
R1421 O_PSET_TAIL.n7 O_PSET_TAIL.t5 0.228
R1422 O_PSET_TAIL.n1 O_PSET_TAIL.t0 0.228
R1423 O_PSET_TAIL.n1 O_PSET_TAIL.t2 0.228
R1424 O_PSET_TAIL.n0 O_PSET_TAIL.t11 0.228
R1425 O_PSET_TAIL.n0 O_PSET_TAIL.t1 0.228
R1426 O_PSET_TAIL.n9 O_PSET_TAIL.n8 0.189974
R1427 O_PSET_TAIL.n8 O_PSET_TAIL.n6 0.189974
R1428 O_PSET_TAIL.n6 O_PSET_TAIL.n4 0.189974
R1429 O_PSET_TAIL O_PSET_TAIL.n10 0.0396304
R1430 E_PSET_TAIL.n10 E_PSET_TAIL.n6 15.4962
R1431 E_PSET_TAIL.n10 E_PSET_TAIL.n9 12.1804
R1432 E_PSET_TAIL.n1 E_PSET_TAIL.t11 5.73764
R1433 E_PSET_TAIL.n6 E_PSET_TAIL.t4 5.54817
R1434 E_PSET_TAIL.n9 E_PSET_TAIL.n7 5.51014
R1435 E_PSET_TAIL.n1 E_PSET_TAIL.n0 5.32067
R1436 E_PSET_TAIL.n3 E_PSET_TAIL.n2 5.32067
R1437 E_PSET_TAIL.n5 E_PSET_TAIL.n4 5.32067
R1438 E_PSET_TAIL.n9 E_PSET_TAIL.n8 5.32067
R1439 E_PSET_TAIL.n0 E_PSET_TAIL.t9 0.228
R1440 E_PSET_TAIL.n0 E_PSET_TAIL.t10 0.228
R1441 E_PSET_TAIL.n2 E_PSET_TAIL.t7 0.228
R1442 E_PSET_TAIL.n2 E_PSET_TAIL.t8 0.228
R1443 E_PSET_TAIL.n4 E_PSET_TAIL.t5 0.228
R1444 E_PSET_TAIL.n4 E_PSET_TAIL.t6 0.228
R1445 E_PSET_TAIL.n7 E_PSET_TAIL.t1 0.228
R1446 E_PSET_TAIL.n7 E_PSET_TAIL.t3 0.228
R1447 E_PSET_TAIL.n8 E_PSET_TAIL.t0 0.228
R1448 E_PSET_TAIL.n8 E_PSET_TAIL.t2 0.228
R1449 E_PSET_TAIL.n6 E_PSET_TAIL.n5 0.189974
R1450 E_PSET_TAIL.n5 E_PSET_TAIL.n3 0.189974
R1451 E_PSET_TAIL.n3 E_PSET_TAIL.n1 0.189974
R1452 E_PSET_TAIL E_PSET_TAIL.n10 0.0396304
R1453 O_QI.n0 O_QI.t19 113.632
R1454 O_QI.n16 O_QI.t12 113.618
R1455 O_QI.n16 O_QI.t13 113.618
R1456 O_QI.n15 O_QI.t16 113.618
R1457 O_QI.n15 O_QI.t17 113.618
R1458 O_QI.n0 O_QI.t18 113.603
R1459 O_QI.n1 O_QI.t15 61.4885
R1460 O_QI.n1 O_QI.t14 61.4598
R1461 O_QI.n2 O_QI.n0 21.3118
R1462 O_QI.n17 O_QI.n15 19.4852
R1463 O_QI.n17 O_QI.n16 17.5287
R1464 O_QI.n2 O_QI.n1 16.2249
R1465 O_QI.n14 O_QI.n2 10.9375
R1466 O_QI.n13 O_QI.n12 9.70485
R1467 O_QI.n7 O_QI.n5 7.43528
R1468 O_QI.n11 O_QI.t2 5.7796
R1469 O_QI.n8 O_QI.t7 5.7796
R1470 O_QI.n6 O_QI.t9 5.73764
R1471 O_QI.n4 O_QI.t4 5.73764
R1472 O_QI.n12 O_QI.t3 5.68486
R1473 O_QI.n5 O_QI.t11 5.6429
R1474 O_QI.n8 O_QI.t8 5.59012
R1475 O_QI.n6 O_QI.t10 5.54817
R1476 O_QI.n11 O_QI.n10 5.38537
R1477 O_QI.n4 O_QI.n3 5.32067
R1478 O_QI.n9 O_QI.n7 4.8918
R1479 O_QI.n7 O_QI.n6 4.5005
R1480 O_QI.n9 O_QI.n8 4.5005
R1481 O_QI.n14 O_QI.n13 4.5005
R1482 O_QI.n18 O_QI.n17 4.5005
R1483 O_QI.n18 O_QI.n14 2.1918
R1484 O_QI.n3 O_QI.t1 0.228
R1485 O_QI.n3 O_QI.t0 0.228
R1486 O_QI.n10 O_QI.t6 0.20525
R1487 O_QI.n10 O_QI.t5 0.20525
R1488 O_QI.n5 O_QI.n4 0.0952368
R1489 O_QI.n12 O_QI.n11 0.0952368
R1490 O_QI.n13 O_QI.n9 0.0787609
R1491 O_QI O_QI.n18 0.0396304
R1492 ODD_DB_BUF.n18 ODD_DB_BUF.t12 113.632
R1493 ODD_DB_BUF.n12 ODD_DB_BUF.t16 113.632
R1494 ODD_DB_BUF.n21 ODD_DB_BUF.t15 109.174
R1495 ODD_DB_BUF.n20 ODD_DB_BUF.t14 109.174
R1496 ODD_DB_BUF.n19 ODD_DB_BUF.t13 109.174
R1497 ODD_DB_BUF.n13 ODD_DB_BUF.t17 109.174
R1498 ODD_DB_BUF.n14 ODD_DB_BUF.t18 109.174
R1499 ODD_DB_BUF.n15 ODD_DB_BUF.t19 109.174
R1500 ODD_DB_BUF.n23 ODD_DB_BUF.n22 21.6707
R1501 ODD_DB_BUF.n22 ODD_DB_BUF.n21 18.4942
R1502 ODD_DB_BUF.n20 ODD_DB_BUF.n17 18.4942
R1503 ODD_DB_BUF.n14 ODD_DB_BUF.n11 18.4942
R1504 ODD_DB_BUF.n16 ODD_DB_BUF.n15 18.4942
R1505 ODD_DB_BUF.n21 ODD_DB_BUF.n20 11.6805
R1506 ODD_DB_BUF.n20 ODD_DB_BUF.n19 11.6805
R1507 ODD_DB_BUF.n14 ODD_DB_BUF.n13 11.6805
R1508 ODD_DB_BUF.n15 ODD_DB_BUF.n14 11.6805
R1509 ODD_DB_BUF.n10 ODD_DB_BUF.n2 10.3701
R1510 ODD_DB_BUF.n23 ODD_DB_BUF.n16 9.77502
R1511 ODD_DB_BUF.n24 ODD_DB_BUF.n10 7.94398
R1512 ODD_DB_BUF.n18 ODD_DB_BUF.n17 7.17687
R1513 ODD_DB_BUF.n12 ODD_DB_BUF.n11 7.17687
R1514 ODD_DB_BUF.n1 ODD_DB_BUF.t11 5.7796
R1515 ODD_DB_BUF.n4 ODD_DB_BUF.t7 5.73764
R1516 ODD_DB_BUF.n8 ODD_DB_BUF.t0 5.73764
R1517 ODD_DB_BUF.n2 ODD_DB_BUF.t8 5.68486
R1518 ODD_DB_BUF.n1 ODD_DB_BUF.n0 5.38537
R1519 ODD_DB_BUF.n4 ODD_DB_BUF.n3 5.32067
R1520 ODD_DB_BUF.n6 ODD_DB_BUF.n5 5.32067
R1521 ODD_DB_BUF.n8 ODD_DB_BUF.n7 5.32067
R1522 ODD_DB_BUF.n10 ODD_DB_BUF.n9 4.5005
R1523 ODD_DB_BUF.n24 ODD_DB_BUF.n23 4.5005
R1524 ODD_DB_BUF.n19 ODD_DB_BUF.n18 4.42851
R1525 ODD_DB_BUF.n13 ODD_DB_BUF.n12 4.42851
R1526 ODD_DB_BUF.n3 ODD_DB_BUF.t5 0.228
R1527 ODD_DB_BUF.n3 ODD_DB_BUF.t6 0.228
R1528 ODD_DB_BUF.n5 ODD_DB_BUF.t3 0.228
R1529 ODD_DB_BUF.n5 ODD_DB_BUF.t4 0.228
R1530 ODD_DB_BUF.n7 ODD_DB_BUF.t1 0.228
R1531 ODD_DB_BUF.n7 ODD_DB_BUF.t2 0.228
R1532 ODD_DB_BUF.n0 ODD_DB_BUF.t9 0.20525
R1533 ODD_DB_BUF.n0 ODD_DB_BUF.t10 0.20525
R1534 ODD_DB_BUF.n6 ODD_DB_BUF.n4 0.189974
R1535 ODD_DB_BUF.n22 ODD_DB_BUF.n17 0.1205
R1536 ODD_DB_BUF.n16 ODD_DB_BUF.n11 0.1205
R1537 ODD_DB_BUF.n9 ODD_DB_BUF.n8 0.0952368
R1538 ODD_DB_BUF.n9 ODD_DB_BUF.n6 0.0952368
R1539 ODD_DB_BUF.n2 ODD_DB_BUF.n1 0.0952368
R1540 ODD_DB_BUF ODD_DB_BUF.n24 0.0396304
R1541 EVEN_DB_BUF.n7 EVEN_DB_BUF.t12 113.632
R1542 EVEN_DB_BUF.n1 EVEN_DB_BUF.t16 113.632
R1543 EVEN_DB_BUF.n10 EVEN_DB_BUF.t15 109.174
R1544 EVEN_DB_BUF.n9 EVEN_DB_BUF.t14 109.174
R1545 EVEN_DB_BUF.n8 EVEN_DB_BUF.t13 109.174
R1546 EVEN_DB_BUF.n2 EVEN_DB_BUF.t17 109.174
R1547 EVEN_DB_BUF.n3 EVEN_DB_BUF.t18 109.174
R1548 EVEN_DB_BUF.n4 EVEN_DB_BUF.t19 109.174
R1549 EVEN_DB_BUF.n12 EVEN_DB_BUF.n11 21.1228
R1550 EVEN_DB_BUF.n11 EVEN_DB_BUF.n10 18.4942
R1551 EVEN_DB_BUF.n9 EVEN_DB_BUF.n6 18.4942
R1552 EVEN_DB_BUF.n3 EVEN_DB_BUF.n0 18.4942
R1553 EVEN_DB_BUF.n5 EVEN_DB_BUF.n4 18.4942
R1554 EVEN_DB_BUF.n10 EVEN_DB_BUF.n9 11.6805
R1555 EVEN_DB_BUF.n9 EVEN_DB_BUF.n8 11.6805
R1556 EVEN_DB_BUF.n3 EVEN_DB_BUF.n2 11.6805
R1557 EVEN_DB_BUF.n4 EVEN_DB_BUF.n3 11.6805
R1558 EVEN_DB_BUF.n23 EVEN_DB_BUF.n15 10.3701
R1559 EVEN_DB_BUF.n12 EVEN_DB_BUF.n5 10.3228
R1560 EVEN_DB_BUF.n7 EVEN_DB_BUF.n6 7.17687
R1561 EVEN_DB_BUF.n1 EVEN_DB_BUF.n0 7.17687
R1562 EVEN_DB_BUF.n24 EVEN_DB_BUF.n12 6.53528
R1563 EVEN_DB_BUF.n14 EVEN_DB_BUF.t11 5.7796
R1564 EVEN_DB_BUF.n17 EVEN_DB_BUF.t7 5.73764
R1565 EVEN_DB_BUF.n21 EVEN_DB_BUF.t0 5.73764
R1566 EVEN_DB_BUF.n15 EVEN_DB_BUF.t8 5.68486
R1567 EVEN_DB_BUF.n14 EVEN_DB_BUF.n13 5.38537
R1568 EVEN_DB_BUF.n17 EVEN_DB_BUF.n16 5.32067
R1569 EVEN_DB_BUF.n19 EVEN_DB_BUF.n18 5.32067
R1570 EVEN_DB_BUF.n21 EVEN_DB_BUF.n20 5.32067
R1571 EVEN_DB_BUF.n24 EVEN_DB_BUF.n23 4.73528
R1572 EVEN_DB_BUF.n23 EVEN_DB_BUF.n22 4.5005
R1573 EVEN_DB_BUF.n8 EVEN_DB_BUF.n7 4.42851
R1574 EVEN_DB_BUF.n2 EVEN_DB_BUF.n1 4.42851
R1575 EVEN_DB_BUF.n16 EVEN_DB_BUF.t5 0.228
R1576 EVEN_DB_BUF.n16 EVEN_DB_BUF.t6 0.228
R1577 EVEN_DB_BUF.n18 EVEN_DB_BUF.t3 0.228
R1578 EVEN_DB_BUF.n18 EVEN_DB_BUF.t4 0.228
R1579 EVEN_DB_BUF.n20 EVEN_DB_BUF.t1 0.228
R1580 EVEN_DB_BUF.n20 EVEN_DB_BUF.t2 0.228
R1581 EVEN_DB_BUF.n13 EVEN_DB_BUF.t9 0.20525
R1582 EVEN_DB_BUF.n13 EVEN_DB_BUF.t10 0.20525
R1583 EVEN_DB_BUF.n19 EVEN_DB_BUF.n17 0.189974
R1584 EVEN_DB_BUF.n11 EVEN_DB_BUF.n6 0.1205
R1585 EVEN_DB_BUF.n5 EVEN_DB_BUF.n0 0.1205
R1586 EVEN_DB_BUF.n22 EVEN_DB_BUF.n21 0.0952368
R1587 EVEN_DB_BUF.n22 EVEN_DB_BUF.n19 0.0952368
R1588 EVEN_DB_BUF.n15 EVEN_DB_BUF.n14 0.0952368
R1589 EVEN_DB_BUF EVEN_DB_BUF.n24 0.0396304
R1590 E_QI.n15 E_QI.t19 113.632
R1591 E_QI.n1 E_QI.t12 113.618
R1592 E_QI.n1 E_QI.t13 113.618
R1593 E_QI.n0 E_QI.t16 113.618
R1594 E_QI.n0 E_QI.t17 113.618
R1595 E_QI.n15 E_QI.t18 113.603
R1596 E_QI.n16 E_QI.t15 61.4885
R1597 E_QI.n16 E_QI.t14 61.4598
R1598 E_QI.n17 E_QI.n15 21.3118
R1599 E_QI.n2 E_QI.n0 20.0331
R1600 E_QI.n2 E_QI.n1 16.9809
R1601 E_QI.n17 E_QI.n16 16.2249
R1602 E_QI.n13 E_QI.n12 9.15702
R1603 E_QI.n7 E_QI.n5 7.43528
R1604 E_QI.n14 E_QI.n2 7.00485
R1605 E_QI.n18 E_QI.n17 6.32007
R1606 E_QI.n11 E_QI.t11 5.7796
R1607 E_QI.n8 E_QI.t0 5.7796
R1608 E_QI.n4 E_QI.t7 5.73764
R1609 E_QI.n6 E_QI.t2 5.73764
R1610 E_QI.n12 E_QI.t8 5.68486
R1611 E_QI.n5 E_QI.t4 5.6429
R1612 E_QI.n8 E_QI.t1 5.59012
R1613 E_QI.n6 E_QI.t3 5.54817
R1614 E_QI.n11 E_QI.n10 5.38537
R1615 E_QI.n4 E_QI.n3 5.32067
R1616 E_QI.n9 E_QI.n7 4.8918
R1617 E_QI.n7 E_QI.n6 4.5005
R1618 E_QI.n9 E_QI.n8 4.5005
R1619 E_QI.n14 E_QI.n13 4.5005
R1620 E_QI.n18 E_QI.n14 4.22659
R1621 E_QI.n13 E_QI.n9 0.626587
R1622 E_QI.n3 E_QI.t5 0.228
R1623 E_QI.n3 E_QI.t6 0.228
R1624 E_QI.n10 E_QI.t9 0.20525
R1625 E_QI.n10 E_QI.t10 0.20525
R1626 E_QI.n5 E_QI.n4 0.0952368
R1627 E_QI.n12 E_QI.n11 0.0952368
R1628 E_QI E_QI.n18 0.0396304
R1629 O_QBBUF.n0 O_QBBUF.t7 113.632
R1630 O_QBBUF.n3 O_QBBUF.t10 113.632
R1631 O_QBBUF.n7 O_QBBUF.t6 113.629
R1632 O_QBBUF.n5 O_QBBUF.t4 109.174
R1633 O_QBBUF.n6 O_QBBUF.t5 109.174
R1634 O_QBBUF.n1 O_QBBUF.t8 109.174
R1635 O_QBBUF.n2 O_QBBUF.t9 109.174
R1636 O_QBBUF.n8 O_QBBUF.n5 18.6022
R1637 O_QBBUF.n9 O_QBBUF.n4 17.394
R1638 O_QBBUF.n6 O_QBBUF.n5 11.6805
R1639 O_QBBUF.n2 O_QBBUF.n1 11.6805
R1640 O_QBBUF.n12 O_QBBUF.n10 10.4648
R1641 O_QBBUF.n9 O_QBBUF.n8 9.21572
R1642 O_QBBUF.n13 O_QBBUF.n9 7.16137
R1643 O_QBBUF.n4 O_QBBUF.n0 7.10487
R1644 O_QBBUF.n4 O_QBBUF.n3 7.10487
R1645 O_QBBUF.n8 O_QBBUF.n7 7.05405
R1646 O_QBBUF.n11 O_QBBUF.t3 6.07983
R1647 O_QBBUF.n11 O_QBBUF.t2 5.89036
R1648 O_QBBUF.n10 O_QBBUF.t1 5.73764
R1649 O_QBBUF.n10 O_QBBUF.t0 5.54817
R1650 O_QBBUF.n13 O_QBBUF.n12 5.43963
R1651 O_QBBUF.n12 O_QBBUF.n11 4.59524
R1652 O_QBBUF.n7 O_QBBUF.n6 4.4296
R1653 O_QBBUF.n1 O_QBBUF.n0 4.42851
R1654 O_QBBUF.n3 O_QBBUF.n2 4.42851
R1655 O_QBBUF O_QBBUF.n13 0.0396304
R1656 O_QBUF.n0 O_QBUF.t7 113.632
R1657 O_QBUF.n3 O_QBUF.t10 113.632
R1658 O_QBUF.n7 O_QBUF.t6 113.629
R1659 O_QBUF.n5 O_QBUF.t4 109.174
R1660 O_QBUF.n6 O_QBUF.t5 109.174
R1661 O_QBUF.n1 O_QBUF.t8 109.174
R1662 O_QBUF.n2 O_QBUF.t9 109.174
R1663 O_QBUF.n8 O_QBUF.n5 18.6022
R1664 O_QBUF.n9 O_QBUF.n4 17.1201
R1665 O_QBUF.n6 O_QBUF.n5 11.6805
R1666 O_QBUF.n2 O_QBUF.n1 11.6805
R1667 O_QBUF.n12 O_QBUF.n10 10.4648
R1668 O_QBUF.n9 O_QBUF.n8 9.48963
R1669 O_QBUF.n13 O_QBUF.n9 7.16137
R1670 O_QBUF.n4 O_QBUF.n0 7.10487
R1671 O_QBUF.n4 O_QBUF.n3 7.10487
R1672 O_QBUF.n8 O_QBUF.n7 7.05405
R1673 O_QBUF.n11 O_QBUF.t2 6.07983
R1674 O_QBUF.n11 O_QBUF.t3 5.89036
R1675 O_QBUF.n10 O_QBUF.t0 5.73764
R1676 O_QBUF.n10 O_QBUF.t1 5.54817
R1677 O_QBUF.n13 O_QBUF.n12 5.16572
R1678 O_QBUF.n12 O_QBUF.n11 4.59524
R1679 O_QBUF.n7 O_QBUF.n6 4.4296
R1680 O_QBUF.n1 O_QBUF.n0 4.42851
R1681 O_QBUF.n3 O_QBUF.n2 4.42851
R1682 O_QBUF O_QBUF.n13 0.0396304
R1683 E_QBUF.n3 E_QBUF.t7 113.632
R1684 E_QBUF.n6 E_QBUF.t10 113.632
R1685 E_QBUF.n10 E_QBUF.t6 113.629
R1686 E_QBUF.n8 E_QBUF.t4 109.174
R1687 E_QBUF.n9 E_QBUF.t5 109.174
R1688 E_QBUF.n4 E_QBUF.t8 109.174
R1689 E_QBUF.n5 E_QBUF.t9 109.174
R1690 E_QBUF.n11 E_QBUF.n8 18.6022
R1691 E_QBUF.n12 E_QBUF.n7 17.6092
R1692 E_QBUF.n9 E_QBUF.n8 11.6805
R1693 E_QBUF.n5 E_QBUF.n4 11.6805
R1694 E_QBUF.n2 E_QBUF.n0 10.4648
R1695 E_QBUF.n12 E_QBUF.n11 9.0005
R1696 E_QBUF.n13 E_QBUF.n2 7.74833
R1697 E_QBUF.n7 E_QBUF.n3 7.10487
R1698 E_QBUF.n7 E_QBUF.n6 7.10487
R1699 E_QBUF.n11 E_QBUF.n10 7.05405
R1700 E_QBUF.n1 E_QBUF.t0 6.07983
R1701 E_QBUF.n1 E_QBUF.t1 5.89036
R1702 E_QBUF.n0 E_QBUF.t2 5.73764
R1703 E_QBUF.n0 E_QBUF.t3 5.54817
R1704 E_QBUF.n2 E_QBUF.n1 4.59524
R1705 E_QBUF.n13 E_QBUF.n12 4.5592
R1706 E_QBUF.n10 E_QBUF.n9 4.4296
R1707 E_QBUF.n4 E_QBUF.n3 4.42851
R1708 E_QBUF.n6 E_QBUF.n5 4.42851
R1709 E_QBUF E_QBUF.n13 0.0396304
R1710 E_QBBUF.n3 E_QBBUF.t7 113.632
R1711 E_QBBUF.n6 E_QBBUF.t10 113.632
R1712 E_QBBUF.n10 E_QBBUF.t6 113.629
R1713 E_QBBUF.n8 E_QBBUF.t4 109.174
R1714 E_QBBUF.n9 E_QBBUF.t5 109.174
R1715 E_QBBUF.n4 E_QBBUF.t8 109.174
R1716 E_QBBUF.n5 E_QBBUF.t9 109.174
R1717 E_QBBUF.n11 E_QBBUF.n8 18.6022
R1718 E_QBBUF.n12 E_QBBUF.n7 17.6092
R1719 E_QBBUF.n9 E_QBBUF.n8 11.6805
R1720 E_QBBUF.n5 E_QBBUF.n4 11.6805
R1721 E_QBBUF.n2 E_QBBUF.n0 10.4648
R1722 E_QBBUF.n12 E_QBBUF.n11 9.0005
R1723 E_QBBUF.n13 E_QBBUF.n2 8.02224
R1724 E_QBBUF.n7 E_QBBUF.n3 7.10487
R1725 E_QBBUF.n7 E_QBBUF.n6 7.10487
R1726 E_QBBUF.n11 E_QBBUF.n10 7.05405
R1727 E_QBBUF.n1 E_QBBUF.t3 6.07983
R1728 E_QBBUF.n1 E_QBBUF.t2 5.89036
R1729 E_QBBUF.n0 E_QBBUF.t1 5.73764
R1730 E_QBBUF.n0 E_QBBUF.t0 5.54817
R1731 E_QBBUF.n13 E_QBBUF.n12 4.83311
R1732 E_QBBUF.n2 E_QBBUF.n1 4.59524
R1733 E_QBBUF.n10 E_QBBUF.n9 4.4296
R1734 E_QBBUF.n4 E_QBBUF.n3 4.42851
R1735 E_QBBUF.n6 E_QBBUF.n5 4.42851
R1736 E_QBBUF E_QBBUF.n13 0.0396304
R1737 O_QBI.n14 O_QBI.t19 113.632
R1738 O_QBI.n4 O_QBI.t12 113.618
R1739 O_QBI.n4 O_QBI.t13 113.618
R1740 O_QBI.n2 O_QBI.t16 113.618
R1741 O_QBI.n2 O_QBI.t17 113.618
R1742 O_QBI.n14 O_QBI.t18 113.603
R1743 O_QBI.n15 O_QBI.t15 61.4885
R1744 O_QBI.n15 O_QBI.t14 61.4598
R1745 O_QBI.n16 O_QBI.n14 21.4318
R1746 O_QBI.n5 O_QBI.n4 17.8026
R1747 O_QBI.n16 O_QBI.n15 16.3449
R1748 O_QBI.n3 O_QBI.n2 16.0613
R1749 O_QBI.n3 O_QBI.n1 14.0679
R1750 O_QBI.n12 O_QBI.n6 9.19615
R1751 O_QBI.n11 O_QBI.n9 7.43528
R1752 O_QBI.n13 O_QBI.n5 7.00485
R1753 O_QBI.n8 O_QBI.t4 5.7796
R1754 O_QBI.n10 O_QBI.t11 5.7796
R1755 O_QBI.n6 O_QBI.t9 5.73764
R1756 O_QBI.n1 O_QBI.t6 5.73764
R1757 O_QBI.n1 O_QBI.t1 5.73764
R1758 O_QBI.n9 O_QBI.t3 5.68486
R1759 O_QBI.n10 O_QBI.t10 5.59012
R1760 O_QBI.n6 O_QBI.t8 5.54817
R1761 O_QBI.n17 O_QBI.n16 5.49833
R1762 O_QBI.n8 O_QBI.n7 5.38537
R1763 O_QBI.n1 O_QBI.n0 5.32067
R1764 O_QBI.n11 O_QBI.n10 4.5005
R1765 O_QBI.n13 O_QBI.n12 4.5005
R1766 O_QBI.n5 O_QBI.n3 3.1505
R1767 O_QBI.n17 O_QBI.n13 2.89615
R1768 O_QBI.n0 O_QBI.t0 0.228
R1769 O_QBI.n0 O_QBI.t7 0.228
R1770 O_QBI.n7 O_QBI.t2 0.20525
R1771 O_QBI.n7 O_QBI.t5 0.20525
R1772 O_QBI.n12 O_QBI.n11 0.196152
R1773 O_QBI.n9 O_QBI.n8 0.0952368
R1774 O_QBI O_QBI.n17 0.0396304
R1775 O_PRST_TAIL.n10 O_PRST_TAIL.n2 19.1064
R1776 O_PRST_TAIL.n10 O_PRST_TAIL.n9 17.603
R1777 O_PRST_TAIL.n4 O_PRST_TAIL.t11 5.73764
R1778 O_PRST_TAIL.n9 O_PRST_TAIL.t4 5.54817
R1779 O_PRST_TAIL.n2 O_PRST_TAIL.n0 5.51014
R1780 O_PRST_TAIL.n4 O_PRST_TAIL.n3 5.32067
R1781 O_PRST_TAIL.n2 O_PRST_TAIL.n1 5.32067
R1782 O_PRST_TAIL.n6 O_PRST_TAIL.n5 5.32067
R1783 O_PRST_TAIL.n8 O_PRST_TAIL.n7 5.32067
R1784 O_PRST_TAIL.n3 O_PRST_TAIL.t9 0.228
R1785 O_PRST_TAIL.n3 O_PRST_TAIL.t10 0.228
R1786 O_PRST_TAIL.n0 O_PRST_TAIL.t3 0.228
R1787 O_PRST_TAIL.n0 O_PRST_TAIL.t2 0.228
R1788 O_PRST_TAIL.n1 O_PRST_TAIL.t1 0.228
R1789 O_PRST_TAIL.n1 O_PRST_TAIL.t0 0.228
R1790 O_PRST_TAIL.n5 O_PRST_TAIL.t7 0.228
R1791 O_PRST_TAIL.n5 O_PRST_TAIL.t8 0.228
R1792 O_PRST_TAIL.n7 O_PRST_TAIL.t5 0.228
R1793 O_PRST_TAIL.n7 O_PRST_TAIL.t6 0.228
R1794 O_PRST_TAIL.n9 O_PRST_TAIL.n8 0.189974
R1795 O_PRST_TAIL.n8 O_PRST_TAIL.n6 0.189974
R1796 O_PRST_TAIL.n6 O_PRST_TAIL.n4 0.189974
R1797 O_PRST_TAIL O_PRST_TAIL.n10 0.0396304
R1798 E_PRST_TAIL.n10 E_PRST_TAIL.n6 24.2305
R1799 E_PRST_TAIL.n10 E_PRST_TAIL.n9 17.0881
R1800 E_PRST_TAIL.n1 E_PRST_TAIL.t2 5.73764
R1801 E_PRST_TAIL.n6 E_PRST_TAIL.t9 5.54817
R1802 E_PRST_TAIL.n9 E_PRST_TAIL.n7 5.51014
R1803 E_PRST_TAIL.n9 E_PRST_TAIL.n8 5.32067
R1804 E_PRST_TAIL.n5 E_PRST_TAIL.n4 5.32067
R1805 E_PRST_TAIL.n3 E_PRST_TAIL.n2 5.32067
R1806 E_PRST_TAIL.n1 E_PRST_TAIL.n0 5.32067
R1807 E_PRST_TAIL.n7 E_PRST_TAIL.t11 0.228
R1808 E_PRST_TAIL.n7 E_PRST_TAIL.t10 0.228
R1809 E_PRST_TAIL.n8 E_PRST_TAIL.t1 0.228
R1810 E_PRST_TAIL.n8 E_PRST_TAIL.t0 0.228
R1811 E_PRST_TAIL.n4 E_PRST_TAIL.t7 0.228
R1812 E_PRST_TAIL.n4 E_PRST_TAIL.t8 0.228
R1813 E_PRST_TAIL.n2 E_PRST_TAIL.t5 0.228
R1814 E_PRST_TAIL.n2 E_PRST_TAIL.t6 0.228
R1815 E_PRST_TAIL.n0 E_PRST_TAIL.t3 0.228
R1816 E_PRST_TAIL.n0 E_PRST_TAIL.t4 0.228
R1817 E_PRST_TAIL.n3 E_PRST_TAIL.n1 0.189974
R1818 E_PRST_TAIL.n5 E_PRST_TAIL.n3 0.189974
R1819 E_PRST_TAIL.n6 E_PRST_TAIL.n5 0.189974
R1820 E_PRST_TAIL E_PRST_TAIL.n10 0.0396304
R1821 E_QBI.n0 E_QBI.t19 113.632
R1822 E_QBI.n15 E_QBI.t12 113.618
R1823 E_QBI.n15 E_QBI.t13 113.618
R1824 E_QBI.n13 E_QBI.t16 113.618
R1825 E_QBI.n13 E_QBI.t17 113.618
R1826 E_QBI.n0 E_QBI.t18 113.603
R1827 E_QBI.n1 E_QBI.t15 61.4885
R1828 E_QBI.n1 E_QBI.t14 61.4598
R1829 E_QBI.n2 E_QBI.n0 21.4318
R1830 E_QBI.n16 E_QBI.n15 17.2548
R1831 E_QBI.n2 E_QBI.n1 16.3449
R1832 E_QBI.n14 E_QBI.n13 16.0613
R1833 E_QBI.n14 E_QBI.n12 14.0679
R1834 E_QBI.n10 E_QBI.n2 10.194
R1835 E_QBI.n5 E_QBI.n3 9.3918
R1836 E_QBI.n9 E_QBI.n8 7.08311
R1837 E_QBI.n7 E_QBI.t8 5.7796
R1838 E_QBI.n4 E_QBI.t3 5.7796
R1839 E_QBI.n3 E_QBI.t1 5.73764
R1840 E_QBI.n12 E_QBI.t10 5.73764
R1841 E_QBI.n12 E_QBI.t7 5.73764
R1842 E_QBI.n8 E_QBI.t5 5.68486
R1843 E_QBI.n4 E_QBI.t2 5.59012
R1844 E_QBI.n3 E_QBI.t0 5.54817
R1845 E_QBI.n7 E_QBI.n6 5.38537
R1846 E_QBI.n12 E_QBI.n11 5.32067
R1847 E_QBI.n5 E_QBI.n4 4.5005
R1848 E_QBI.n10 E_QBI.n9 4.5005
R1849 E_QBI.n17 E_QBI.n16 4.5005
R1850 E_QBI.n16 E_QBI.n14 3.69833
R1851 E_QBI.n17 E_QBI.n10 2.1918
R1852 E_QBI.n9 E_QBI.n5 0.352674
R1853 E_QBI.n11 E_QBI.t6 0.228
R1854 E_QBI.n11 E_QBI.t11 0.228
R1855 E_QBI.n6 E_QBI.t4 0.20525
R1856 E_QBI.n6 E_QBI.t9 0.20525
R1857 E_QBI.n8 E_QBI.n7 0.0952368
R1858 E_QBI E_QBI.n17 0.0396304
R1859 ODD_D_BUF.n19 ODD_D_BUF.t12 113.632
R1860 ODD_D_BUF.n12 ODD_D_BUF.t19 113.632
R1861 ODD_D_BUF.n22 ODD_D_BUF.t15 109.174
R1862 ODD_D_BUF.n21 ODD_D_BUF.t14 109.174
R1863 ODD_D_BUF.n20 ODD_D_BUF.t13 109.174
R1864 ODD_D_BUF.n15 ODD_D_BUF.t16 109.174
R1865 ODD_D_BUF.n14 ODD_D_BUF.t17 109.174
R1866 ODD_D_BUF.n13 ODD_D_BUF.t18 109.174
R1867 ODD_D_BUF.n24 ODD_D_BUF.n23 23.4289
R1868 ODD_D_BUF.n17 ODD_D_BUF.n16 20.1159
R1869 ODD_D_BUF.n23 ODD_D_BUF.n22 18.4942
R1870 ODD_D_BUF.n21 ODD_D_BUF.n18 18.4942
R1871 ODD_D_BUF.n16 ODD_D_BUF.n15 18.4942
R1872 ODD_D_BUF.n14 ODD_D_BUF.n11 18.4942
R1873 ODD_D_BUF.n22 ODD_D_BUF.n21 11.6805
R1874 ODD_D_BUF.n21 ODD_D_BUF.n20 11.6805
R1875 ODD_D_BUF.n15 ODD_D_BUF.n14 11.6805
R1876 ODD_D_BUF.n14 ODD_D_BUF.n13 11.6805
R1877 ODD_D_BUF.n10 ODD_D_BUF.n2 10.3701
R1878 ODD_D_BUF.n17 ODD_D_BUF.n10 8.45267
R1879 ODD_D_BUF.n19 ODD_D_BUF.n18 7.17687
R1880 ODD_D_BUF.n12 ODD_D_BUF.n11 7.17687
R1881 ODD_D_BUF.n1 ODD_D_BUF.t11 5.7796
R1882 ODD_D_BUF.n4 ODD_D_BUF.t7 5.73764
R1883 ODD_D_BUF.n8 ODD_D_BUF.t0 5.73764
R1884 ODD_D_BUF.n2 ODD_D_BUF.t8 5.68486
R1885 ODD_D_BUF.n1 ODD_D_BUF.n0 5.38537
R1886 ODD_D_BUF.n4 ODD_D_BUF.n3 5.32067
R1887 ODD_D_BUF.n6 ODD_D_BUF.n5 5.32067
R1888 ODD_D_BUF.n8 ODD_D_BUF.n7 5.32067
R1889 ODD_D_BUF.n10 ODD_D_BUF.n9 4.5005
R1890 ODD_D_BUF.n20 ODD_D_BUF.n19 4.42851
R1891 ODD_D_BUF.n13 ODD_D_BUF.n12 4.42851
R1892 ODD_D_BUF.n24 ODD_D_BUF.n17 3.75702
R1893 ODD_D_BUF.n3 ODD_D_BUF.t5 0.228
R1894 ODD_D_BUF.n3 ODD_D_BUF.t6 0.228
R1895 ODD_D_BUF.n5 ODD_D_BUF.t3 0.228
R1896 ODD_D_BUF.n5 ODD_D_BUF.t4 0.228
R1897 ODD_D_BUF.n7 ODD_D_BUF.t1 0.228
R1898 ODD_D_BUF.n7 ODD_D_BUF.t2 0.228
R1899 ODD_D_BUF.n0 ODD_D_BUF.t9 0.20525
R1900 ODD_D_BUF.n0 ODD_D_BUF.t10 0.20525
R1901 ODD_D_BUF.n6 ODD_D_BUF.n4 0.189974
R1902 ODD_D_BUF.n23 ODD_D_BUF.n18 0.1205
R1903 ODD_D_BUF.n16 ODD_D_BUF.n11 0.1205
R1904 ODD_D_BUF.n9 ODD_D_BUF.n8 0.0952368
R1905 ODD_D_BUF.n9 ODD_D_BUF.n6 0.0952368
R1906 ODD_D_BUF.n2 ODD_D_BUF.n1 0.0952368
R1907 ODD_D_BUF ODD_D_BUF.n24 0.0396304
R1908 EVEN_D_BUF.n1 EVEN_D_BUF.t12 113.632
R1909 EVEN_D_BUF.n7 EVEN_D_BUF.t16 113.632
R1910 EVEN_D_BUF.n4 EVEN_D_BUF.t15 109.174
R1911 EVEN_D_BUF.n3 EVEN_D_BUF.t14 109.174
R1912 EVEN_D_BUF.n2 EVEN_D_BUF.t13 109.174
R1913 EVEN_D_BUF.n8 EVEN_D_BUF.t17 109.174
R1914 EVEN_D_BUF.n9 EVEN_D_BUF.t18 109.174
R1915 EVEN_D_BUF.n10 EVEN_D_BUF.t19 109.174
R1916 EVEN_D_BUF.n12 EVEN_D_BUF.n5 25.855
R1917 EVEN_D_BUF.n12 EVEN_D_BUF.n11 20.5437
R1918 EVEN_D_BUF.n5 EVEN_D_BUF.n4 18.4942
R1919 EVEN_D_BUF.n3 EVEN_D_BUF.n0 18.4942
R1920 EVEN_D_BUF.n9 EVEN_D_BUF.n6 18.4942
R1921 EVEN_D_BUF.n11 EVEN_D_BUF.n10 18.4942
R1922 EVEN_D_BUF.n4 EVEN_D_BUF.n3 11.6805
R1923 EVEN_D_BUF.n3 EVEN_D_BUF.n2 11.6805
R1924 EVEN_D_BUF.n9 EVEN_D_BUF.n8 11.6805
R1925 EVEN_D_BUF.n10 EVEN_D_BUF.n9 11.6805
R1926 EVEN_D_BUF.n23 EVEN_D_BUF.n22 10.3309
R1927 EVEN_D_BUF.n1 EVEN_D_BUF.n0 7.17687
R1928 EVEN_D_BUF.n7 EVEN_D_BUF.n6 7.17687
R1929 EVEN_D_BUF.n21 EVEN_D_BUF.t11 5.7796
R1930 EVEN_D_BUF.n14 EVEN_D_BUF.t7 5.73764
R1931 EVEN_D_BUF.n18 EVEN_D_BUF.t0 5.73764
R1932 EVEN_D_BUF.n22 EVEN_D_BUF.t8 5.68486
R1933 EVEN_D_BUF.n21 EVEN_D_BUF.n20 5.38537
R1934 EVEN_D_BUF.n14 EVEN_D_BUF.n13 5.32067
R1935 EVEN_D_BUF.n16 EVEN_D_BUF.n15 5.32067
R1936 EVEN_D_BUF.n18 EVEN_D_BUF.n17 5.32067
R1937 EVEN_D_BUF.n23 EVEN_D_BUF.n19 4.53963
R1938 EVEN_D_BUF.n24 EVEN_D_BUF.n23 4.5005
R1939 EVEN_D_BUF.n2 EVEN_D_BUF.n1 4.42851
R1940 EVEN_D_BUF.n8 EVEN_D_BUF.n7 4.42851
R1941 EVEN_D_BUF.n24 EVEN_D_BUF.n12 3.91354
R1942 EVEN_D_BUF.n13 EVEN_D_BUF.t5 0.228
R1943 EVEN_D_BUF.n13 EVEN_D_BUF.t6 0.228
R1944 EVEN_D_BUF.n15 EVEN_D_BUF.t3 0.228
R1945 EVEN_D_BUF.n15 EVEN_D_BUF.t4 0.228
R1946 EVEN_D_BUF.n17 EVEN_D_BUF.t1 0.228
R1947 EVEN_D_BUF.n17 EVEN_D_BUF.t2 0.228
R1948 EVEN_D_BUF.n20 EVEN_D_BUF.t9 0.20525
R1949 EVEN_D_BUF.n20 EVEN_D_BUF.t10 0.20525
R1950 EVEN_D_BUF.n16 EVEN_D_BUF.n14 0.189974
R1951 EVEN_D_BUF.n5 EVEN_D_BUF.n0 0.1205
R1952 EVEN_D_BUF.n11 EVEN_D_BUF.n6 0.1205
R1953 EVEN_D_BUF.n19 EVEN_D_BUF.n18 0.0952368
R1954 EVEN_D_BUF.n19 EVEN_D_BUF.n16 0.0952368
R1955 EVEN_D_BUF.n22 EVEN_D_BUF.n21 0.0952368
R1956 EVEN_D_BUF EVEN_D_BUF.n24 0.0396304
C0 O_SET_TAIL O_RST_TAIL 0.70351f
C1 EVEN_CAPTURE_CLKB E_PSET_TAIL 3.32426f
C2 EVEN_D_BUF EVEN_D 0.04189f
C3 O_QBBUF ODD_D_BUF 2.37715f
C4 E_QI EVEN_D_BUF 0.74882f
C5 EVEN_DB EVEN_CAPTURE_CLKB 0.12139f
C6 ODD_DB_BUF O_RST_TAIL 0.56945f
C7 E_PRST_TAIL E_QBUF 0.53754f
C8 VDD O_QBUF 6.35692f
C9 VDD EVEN_Q 7.31561f
C10 EVEN_CAPTURE_CLKB E_QBI 0.12357f
C11 E_SET_TAIL EVEN_D_BUF 0.61506f
C12 E_PSET_TAIL E_QBI 0.20078f
C13 VDD ODD_CAPTURE_CLKB 8.87539f
C14 ODD_D_BUF ODD_D 0.02446f
C15 O_PRST_TAIL VDD 15.3169f
C16 E_QBBUF VDD 6.44257f
C17 EVEN_QB EVEN_CAPTURE_CLKB 0.70057f
C18 ODD_QB VDD 7.42733f
C19 E_PRST_TAIL VDD 16.0147f
C20 ODD_CAPTURE_CLK O_QI 0.16467f
C21 EVEN_QB E_PSET_TAIL 0.02064f
C22 ODD_DB_BUF ODD_CAPTURE_CLKB 0.81461f
C23 EVEN_CAPTURE_CLK E_RST_TAIL 1.16209f
C24 ODD_DB ODD_QB 0.09326f
C25 O_QBI O_QI 8.49253f
C26 ODD_DB_BUF O_PRST_TAIL 0.86137f
C27 EVEN_QB EVEN_DB 0.06902f
C28 E_QI EVEN_D 0.09054f
C29 O_RST_TAIL ODD_D_BUF 0.70292f
C30 ODD_DB_BUF ODD_QB 0.17063f
C31 EVEN_QB E_QBI 0.15538f
C32 EVEN_DB_BUF E_PRST_TAIL 0.13174f
C33 E_QI E_SET_TAIL 0.76857f
C34 E_RST_TAIL EVEN_D_BUF 0.37995f
C35 VDD EVEN_D_BUF 14.4587f
C36 EVEN_DB_BUF EVEN_CAPTURE_CLK 0.15269f
C37 O_QBUF ODD_D_BUF 0.28842f
C38 O_PSET_TAIL O_QBUF 0.04525f
C39 ODD_CAPTURE_CLKB ODD_D_BUF 0.70031f
C40 EVEN_CAPTURE_CLKB EVEN_Q 0.10117f
C41 ODD_CAPTURE_CLKB O_PSET_TAIL 2.02608f
C42 O_PRST_TAIL ODD_D_BUF 0.78807f
C43 VDD O_QI 7.2336f
C44 O_PRST_TAIL O_PSET_TAIL 1.05443f
C45 O_SET_TAIL O_QI 0.48793f
C46 ODD_QB ODD_D_BUF 0.15391f
C47 ODD_QB O_PSET_TAIL 0.21495f
C48 ODD_Q VDD 7.41927f
C49 ODD_DB O_QI 0.57789f
C50 ODD_CAPTURE_CLK O_QBI 0.04327f
C51 EVEN_DB_BUF EVEN_D_BUF 0.97829f
C52 E_QBBUF EVEN_CAPTURE_CLKB 0.15018f
C53 E_QI E_QBUF 0.06057f
C54 E_PRST_TAIL EVEN_CAPTURE_CLKB 0.94605f
C55 ODD_DB_BUF O_QI 3.71826f
C56 O_QBBUF ODD_CAPTURE_CLKB 0.16758f
C57 E_PRST_TAIL E_PSET_TAIL 1.95856f
C58 E_QBBUF EVEN_DB 0.14911f
C59 VDD EVEN_D 2.45627f
C60 O_QBBUF ODD_QB 0.15023f
C61 E_QI E_RST_TAIL 4.88428f
C62 E_QI VDD 7.23216f
C63 EVEN_QB EVEN_Q 0.47433f
C64 E_PRST_TAIL E_QBI 5.5293f
C65 EVEN_CAPTURE_CLK EVEN_DB 0.49922f
C66 E_RST_TAIL E_SET_TAIL 0.57545f
C67 E_QBBUF EVEN_QB 0.17621f
C68 ODD_QB ODD_D 0.10247f
C69 EVEN_CAPTURE_CLKB EVEN_D_BUF 0.42228f
C70 E_PRST_TAIL EVEN_QB 0.0844f
C71 ODD_CAPTURE_CLK O_SET_TAIL 1.51208f
C72 EVEN_DB_BUF EVEN_D 3.50536f
C73 O_QI ODD_D_BUF 0.70423f
C74 E_PSET_TAIL EVEN_D_BUF 0.4182f
C75 O_QI O_PSET_TAIL 5.10737f
C76 O_QBI VDD 8.6014f
C77 EVEN_DB_BUF E_QI 3.57751f
C78 ODD_CAPTURE_CLK ODD_DB 0.29797f
C79 O_QBI O_SET_TAIL 4.91815f
C80 EVEN_DB EVEN_D_BUF 3.45509f
C81 ODD_CAPTURE_CLK ODD_DB_BUF 0.32291f
C82 EVEN_DB_BUF E_SET_TAIL 0.71109f
C83 EVEN_D_BUF E_QBI 4.77076f
C84 ODD_DB_BUF O_QBI 0.19065f
C85 VDD E_QBUF 7.45153f
C86 O_QBBUF O_QI 0.68141f
C87 EVEN_QB EVEN_D_BUF 0.13958f
C88 O_QBBUF ODD_Q 4.18276f
C89 O_PRST_TAIL O_QBUF 1.54979f
C90 EVEN_CAPTURE_CLKB EVEN_D 0.13427f
C91 E_QBBUF EVEN_Q 4.25991f
C92 ODD_QB O_QBUF 4.17728f
C93 E_QI EVEN_CAPTURE_CLKB 0.15555f
C94 O_PRST_TAIL ODD_CAPTURE_CLKB 3.41065f
C95 O_QI ODD_D 0.08214f
C96 E_QI E_PSET_TAIL 5.13429f
C97 ODD_QB ODD_CAPTURE_CLKB 0.10357f
C98 ODD_CAPTURE_CLK ODD_D_BUF 0.0367f
C99 ODD_DB VDD 2.43356f
C100 EVEN_DB EVEN_D 1.31868f
C101 O_PRST_TAIL ODD_QB 0.43511f
C102 E_QI EVEN_DB 0.51392f
C103 O_QBI ODD_D_BUF 4.78972f
C104 O_QBI O_PSET_TAIL 0.30508f
C105 ODD_DB_BUF VDD 13.0218f
C106 E_QI E_QBI 8.54354f
C107 EVEN_DB_BUF E_RST_TAIL 0.50524f
C108 ODD_DB_BUF O_SET_TAIL 0.54226f
C109 EVEN_DB_BUF VDD 12.9418f
C110 O_RST_TAIL O_QI 4.94403f
C111 E_SET_TAIL E_QBI 4.91367f
C112 EVEN_QB EVEN_D 0.07547f
C113 E_QI EVEN_QB 0.33632f
C114 E_QBBUF EVEN_D_BUF 2.27875f
C115 ODD_CAPTURE_CLK ODD_D 0.09142f
C116 E_PRST_TAIL EVEN_D_BUF 3.77728f
C117 VDD ODD_D_BUF 15.6002f
C118 O_QI ODD_CAPTURE_CLKB 0.15737f
C119 VDD O_PSET_TAIL 13.1964f
C120 O_SET_TAIL ODD_D_BUF 0.53742f
C121 O_PRST_TAIL O_QI 0.29363f
C122 VDD EVEN_CAPTURE_CLKB 9.04828f
C123 E_QBUF E_QBI 0.99299f
C124 ODD_DB ODD_D_BUF 3.44145f
C125 EVEN_CAPTURE_CLK EVEN_D_BUF 0.10379f
C126 ODD_Q ODD_CAPTURE_CLKB 0.07511f
C127 ODD_QB O_QI 0.23682f
C128 VDD E_PSET_TAIL 11.6748f
C129 ODD_DB_BUF ODD_D_BUF 1.07149f
C130 ODD_DB_BUF O_PSET_TAIL 0.68175f
C131 ODD_QB ODD_Q 0.51937f
C132 EVEN_DB VDD 2.42899f
C133 ODD_CAPTURE_CLK O_RST_TAIL 2.06628f
C134 EVEN_QB E_QBUF 4.13702f
C135 E_RST_TAIL E_QBI 0.01355f
C136 O_QBBUF VDD 6.75866f
C137 VDD E_QBI 8.55614f
C138 O_QBI O_RST_TAIL 0.0736f
C139 EVEN_DB_BUF EVEN_CAPTURE_CLKB 0.19022f
C140 ODD_DB O_QBBUF 0.20592f
C141 EVEN_DB_BUF E_PSET_TAIL 1.81361f
C142 E_QI E_QBBUF 0.60128f
C143 VDD ODD_D 2.45251f
C144 EVEN_QB VDD 8.86516f
C145 E_QI E_PRST_TAIL 0.2741f
C146 O_QBI O_QBUF 1.08164f
C147 EVEN_DB_BUF E_QBI 0.0643f
C148 EVEN_CAPTURE_CLK EVEN_D 0.23696f
C149 ODD_DB ODD_D 1.31868f
C150 EVEN_CAPTURE_CLK E_QI 0.1853f
C151 O_PSET_TAIL ODD_D_BUF 1.09217f
C152 O_QBI ODD_CAPTURE_CLKB 0.07731f
C153 ODD_DB_BUF ODD_D 3.49863f
C154 O_PRST_TAIL O_QBI 5.53402f
C155 EVEN_CAPTURE_CLK E_SET_TAIL 1.75694f
C156 O_QBI ODD_QB 0.15666f
C157 EVEN_DB_BUF EVEN_QB 0.15519f
C158 ODD_CAPTURE_CLK VSS 11.94057f
C159 EVEN_CAPTURE_CLK VSS 11.49734f
C160 ODD_DB VSS 7.9156f
C161 ODD_D VSS 8.29825f
C162 EVEN_D VSS 8.55348f
C163 EVEN_DB VSS 7.90418f
C164 ODD_Q VSS 5.29541f
C165 ODD_QB VSS 9.73643f
C166 EVEN_QB VSS 9.40271f
C167 EVEN_Q VSS 5.60206f
C168 ODD_CAPTURE_CLKB VSS 4.02879f
C169 EVEN_CAPTURE_CLKB VSS 3.88386f
C170 VDD VSS 1.38458p
C171 O_RST_TAIL VSS 14.07966f
C172 E_RST_TAIL VSS 13.39666f
C173 O_SET_TAIL VSS 11.53561f
C174 E_SET_TAIL VSS 11.52819f
C175 O_PSET_TAIL VSS 0.23222f
C176 E_PSET_TAIL VSS 0.15708f
C177 O_QI VSS 12.92366f
C178 ODD_DB_BUF VSS 9.94886f
C179 EVEN_DB_BUF VSS 10.20984f
C180 E_QI VSS 12.05724f
C181 O_QBBUF VSS 5.49643f
C182 O_QBUF VSS 5.2576f
C183 E_QBUF VSS 5.25384f
C184 E_QBBUF VSS 6.1426f
C185 O_QBI VSS 10.9368f
C186 O_PRST_TAIL VSS 0.25423f
C187 E_PRST_TAIL VSS 0.7023f
C188 E_QBI VSS 11.57232f
C189 ODD_D_BUF VSS 9.0285f
C190 EVEN_D_BUF VSS 9.21535f
C191 EVEN_D_BUF.n0 VSS 0.33787f
C192 EVEN_D_BUF.n1 VSS 0.167f
C193 EVEN_D_BUF.n2 VSS 0.17901f
C194 EVEN_D_BUF.n3 VSS 0.17901f
C195 EVEN_D_BUF.n4 VSS 0.16919f
C196 EVEN_D_BUF.n5 VSS 2.35908f
C197 EVEN_D_BUF.n6 VSS 0.33787f
C198 EVEN_D_BUF.n7 VSS 0.167f
C199 EVEN_D_BUF.n8 VSS 0.17901f
C200 EVEN_D_BUF.n9 VSS 0.17901f
C201 EVEN_D_BUF.n10 VSS 0.16919f
C202 EVEN_D_BUF.n11 VSS 1.74903f
C203 EVEN_D_BUF.n12 VSS 6.49498f
C204 EVEN_D_BUF.t7 VSS 1.40931f
C205 EVEN_D_BUF.t6 VSS 0.30782f
C206 EVEN_D_BUF.t5 VSS 0.30782f
C207 EVEN_D_BUF.n13 VSS 1.05802f
C208 EVEN_D_BUF.n14 VSS 0.58156f
C209 EVEN_D_BUF.t4 VSS 0.30782f
C210 EVEN_D_BUF.t3 VSS 0.30782f
C211 EVEN_D_BUF.n15 VSS 1.05802f
C212 EVEN_D_BUF.n16 VSS 0.24384f
C213 EVEN_D_BUF.t0 VSS 1.40931f
C214 EVEN_D_BUF.t2 VSS 0.30782f
C215 EVEN_D_BUF.t1 VSS 0.30782f
C216 EVEN_D_BUF.n17 VSS 1.05802f
C217 EVEN_D_BUF.n18 VSS 0.52181f
C218 EVEN_D_BUF.n19 VSS 0.11987f
C219 EVEN_D_BUF.t11 VSS 1.40679f
C220 EVEN_D_BUF.t10 VSS 0.30782f
C221 EVEN_D_BUF.t9 VSS 0.30782f
C222 EVEN_D_BUF.n20 VSS 1.05022f
C223 EVEN_D_BUF.n21 VSS 0.53214f
C224 EVEN_D_BUF.t8 VSS 1.40112f
C225 EVEN_D_BUF.n22 VSS 1.12558f
C226 EVEN_D_BUF.n23 VSS 2.00088f
C227 EVEN_D_BUF.n24 VSS 0.91311f
C228 ODD_D_BUF.t11 VSS 1.37547f
C229 ODD_D_BUF.t10 VSS 0.3015f
C230 ODD_D_BUF.t9 VSS 0.3015f
C231 ODD_D_BUF.n0 VSS 1.02631f
C232 ODD_D_BUF.n1 VSS 0.52003f
C233 ODD_D_BUF.t8 VSS 1.36993f
C234 ODD_D_BUF.n2 VSS 1.10718f
C235 ODD_D_BUF.t7 VSS 1.37793f
C236 ODD_D_BUF.t6 VSS 0.3015f
C237 ODD_D_BUF.t5 VSS 0.3015f
C238 ODD_D_BUF.n3 VSS 1.03394f
C239 ODD_D_BUF.n4 VSS 0.56832f
C240 ODD_D_BUF.t4 VSS 0.3015f
C241 ODD_D_BUF.t3 VSS 0.3015f
C242 ODD_D_BUF.n5 VSS 1.03394f
C243 ODD_D_BUF.n6 VSS 0.23829f
C244 ODD_D_BUF.t0 VSS 1.37793f
C245 ODD_D_BUF.t2 VSS 0.3015f
C246 ODD_D_BUF.t1 VSS 0.3015f
C247 ODD_D_BUF.n7 VSS 1.03394f
C248 ODD_D_BUF.n8 VSS 0.50994f
C249 ODD_D_BUF.n9 VSS 0.11677f
C250 ODD_D_BUF.n10 VSS 2.49968f
C251 ODD_D_BUF.n11 VSS 0.33018f
C252 ODD_D_BUF.n12 VSS 0.1632f
C253 ODD_D_BUF.n13 VSS 0.17494f
C254 ODD_D_BUF.n14 VSS 0.17494f
C255 ODD_D_BUF.n15 VSS 0.16534f
C256 ODD_D_BUF.n16 VSS 1.68882f
C257 ODD_D_BUF.n17 VSS 3.87033f
C258 ODD_D_BUF.n18 VSS 0.33018f
C259 ODD_D_BUF.n19 VSS 0.1632f
C260 ODD_D_BUF.n20 VSS 0.17494f
C261 ODD_D_BUF.n21 VSS 0.17494f
C262 ODD_D_BUF.n22 VSS 0.16534f
C263 ODD_D_BUF.n23 VSS 2.03798f
C264 ODD_D_BUF.n24 VSS 3.56901f
C265 E_QBI.n0 VSS 0.8476f
C266 E_QBI.n1 VSS 0.44022f
C267 E_QBI.n2 VSS 3.2176f
C268 E_QBI.t1 VSS 1.32164f
C269 E_QBI.t0 VSS 1.3132f
C270 E_QBI.n3 VSS 1.04237f
C271 E_QBI.t3 VSS 1.31939f
C272 E_QBI.t2 VSS 1.31094f
C273 E_QBI.n4 VSS 0.50744f
C274 E_QBI.n5 VSS 1.57382f
C275 E_QBI.t8 VSS 1.33461f
C276 E_QBI.t9 VSS 0.35555f
C277 E_QBI.t4 VSS 0.35555f
C278 E_QBI.n6 VSS 0.93413f
C279 E_QBI.n7 VSS 0.47332f
C280 E_QBI.t5 VSS 1.32624f
C281 E_QBI.n8 VSS 0.51234f
C282 E_QBI.n9 VSS 0.95972f
C283 E_QBI.n10 VSS 1.87916f
C284 E_QBI.t10 VSS 1.33686f
C285 E_QBI.t11 VSS 0.35555f
C286 E_QBI.t6 VSS 0.35555f
C287 E_QBI.n11 VSS 0.94107f
C288 E_QBI.t7 VSS 1.33353f
C289 E_QBI.n12 VSS 2.12247f
C290 E_QBI.n13 VSS 0.42152f
C291 E_QBI.n14 VSS 3.48665f
C292 E_QBI.n15 VSS 0.44903f
C293 E_QBI.n16 VSS 1.3754f
C294 E_QBI.n17 VSS 0.45836f
C295 E_PRST_TAIL.t2 VSS 1.73064f
C296 E_PRST_TAIL.t4 VSS 0.38643f
C297 E_PRST_TAIL.t3 VSS 0.38643f
C298 E_PRST_TAIL.n0 VSS 1.29348f
C299 E_PRST_TAIL.n1 VSS 0.71098f
C300 E_PRST_TAIL.t6 VSS 0.38643f
C301 E_PRST_TAIL.t5 VSS 0.38643f
C302 E_PRST_TAIL.n2 VSS 1.29348f
C303 E_PRST_TAIL.n3 VSS 0.37115f
C304 E_PRST_TAIL.t8 VSS 0.38643f
C305 E_PRST_TAIL.t7 VSS 0.38643f
C306 E_PRST_TAIL.n4 VSS 1.29348f
C307 E_PRST_TAIL.n5 VSS 0.37115f
C308 E_PRST_TAIL.t9 VSS 1.72165f
C309 E_PRST_TAIL.n6 VSS 5.15801f
C310 E_PRST_TAIL.t10 VSS 0.42697f
C311 E_PRST_TAIL.t11 VSS 0.42364f
C312 E_PRST_TAIL.n7 VSS 1.3036f
C313 E_PRST_TAIL.t0 VSS 0.42364f
C314 E_PRST_TAIL.t1 VSS 0.42364f
C315 E_PRST_TAIL.n8 VSS 1.29348f
C316 E_PRST_TAIL.n9 VSS 3.32528f
C317 E_PRST_TAIL.n10 VSS 7.13643f
C318 O_PRST_TAIL.t2 VSS 0.45282f
C319 O_PRST_TAIL.t3 VSS 0.45282f
C320 O_PRST_TAIL.n0 VSS 1.47647f
C321 O_PRST_TAIL.t0 VSS 0.45282f
C322 O_PRST_TAIL.t1 VSS 0.45607f
C323 O_PRST_TAIL.n1 VSS 1.465f
C324 O_PRST_TAIL.n2 VSS 3.90155f
C325 O_PRST_TAIL.t11 VSS 1.95692f
C326 O_PRST_TAIL.t10 VSS 0.4316f
C327 O_PRST_TAIL.t9 VSS 0.4316f
C328 O_PRST_TAIL.n3 VSS 1.465f
C329 O_PRST_TAIL.n4 VSS 0.80527f
C330 O_PRST_TAIL.t8 VSS 0.4316f
C331 O_PRST_TAIL.t7 VSS 0.4316f
C332 O_PRST_TAIL.n5 VSS 1.465f
C333 O_PRST_TAIL.n6 VSS 0.42037f
C334 O_PRST_TAIL.t6 VSS 0.4316f
C335 O_PRST_TAIL.t5 VSS 0.4316f
C336 O_PRST_TAIL.n7 VSS 1.465f
C337 O_PRST_TAIL.n8 VSS 0.42037f
C338 O_PRST_TAIL.t4 VSS 1.94092f
C339 O_PRST_TAIL.n9 VSS 3.43587f
C340 O_PRST_TAIL.n10 VSS 6.46094f
C341 O_QBI.t6 VSS 1.36469f
C342 O_QBI.t7 VSS 0.3571f
C343 O_QBI.t0 VSS 0.3571f
C344 O_QBI.n0 VSS 0.96955f
C345 O_QBI.t1 VSS 1.36794f
C346 O_QBI.n1 VSS 2.18672f
C347 O_QBI.n2 VSS 0.43427f
C348 O_QBI.n3 VSS 3.47621f
C349 O_QBI.n4 VSS 0.4857f
C350 O_QBI.n5 VSS 1.71077f
C351 O_QBI.t9 VSS 1.3555f
C352 O_QBI.t8 VSS 1.3468f
C353 O_QBI.n6 VSS 1.0419f
C354 O_QBI.t4 VSS 1.36562f
C355 O_QBI.t5 VSS 0.3571f
C356 O_QBI.t2 VSS 0.3571f
C357 O_QBI.n7 VSS 0.9624f
C358 O_QBI.n8 VSS 0.48764f
C359 O_QBI.t3 VSS 1.35718f
C360 O_QBI.n9 VSS 0.57469f
C361 O_QBI.t11 VSS 1.35318f
C362 O_QBI.t10 VSS 1.34447f
C363 O_QBI.n10 VSS 0.5228f
C364 O_QBI.n11 VSS 1.05792f
C365 O_QBI.n12 VSS 1.53751f
C366 O_QBI.n13 VSS 1.50417f
C367 O_QBI.n14 VSS 0.87326f
C368 O_QBI.n15 VSS 0.45355f
C369 O_QBI.n16 VSS 2.72322f
C370 O_QBI.n17 VSS 0.66541f
C371 E_QBBUF.t1 VSS 1.15834f
C372 E_QBBUF.t0 VSS 1.15111f
C373 E_QBBUF.n0 VSS 1.11868f
C374 E_QBBUF.t3 VSS 0.55608f
C375 E_QBBUF.t2 VSS 0.54971f
C376 E_QBBUF.n1 VSS 0.49446f
C377 E_QBBUF.n2 VSS 2.10122f
C378 E_QBBUF.n3 VSS 0.12582f
C379 E_QBBUF.n4 VSS 0.13681f
C380 E_QBBUF.n5 VSS 0.13681f
C381 E_QBBUF.n6 VSS 0.12582f
C382 E_QBBUF.n7 VSS 1.1405f
C383 E_QBBUF.n8 VSS 0.12979f
C384 E_QBBUF.n9 VSS 0.13681f
C385 E_QBBUF.n10 VSS 0.1247f
C386 E_QBBUF.n11 VSS 0.29031f
C387 E_QBBUF.n12 VSS 2.47221f
C388 E_QBBUF.n13 VSS 0.71331f
C389 E_QBUF.t2 VSS 1.10547f
C390 E_QBUF.t3 VSS 1.09859f
C391 E_QBUF.n0 VSS 1.06423f
C392 E_QBUF.t0 VSS 0.5309f
C393 E_QBUF.t1 VSS 0.52485f
C394 E_QBUF.n1 VSS 0.47039f
C395 E_QBUF.n2 VSS 1.92533f
C396 E_QBUF.n3 VSS 0.11969f
C397 E_QBUF.n4 VSS 0.13015f
C398 E_QBUF.n5 VSS 0.13015f
C399 E_QBUF.n6 VSS 0.11969f
C400 E_QBUF.n7 VSS 1.08499f
C401 E_QBUF.n8 VSS 0.12347f
C402 E_QBUF.n9 VSS 0.13015f
C403 E_QBUF.n10 VSS 0.11863f
C404 E_QBUF.n11 VSS 0.27618f
C405 E_QBUF.n12 VSS 2.26498f
C406 E_QBUF.n13 VSS 0.65507f
C407 O_QBUF.n0 VSS 0.12253f
C408 O_QBUF.n1 VSS 0.13323f
C409 O_QBUF.n2 VSS 0.13323f
C410 O_QBUF.n3 VSS 0.12253f
C411 O_QBUF.n4 VSS 1.04857f
C412 O_QBUF.n5 VSS 0.12639f
C413 O_QBUF.n6 VSS 0.13323f
C414 O_QBUF.n7 VSS 0.12143f
C415 O_QBUF.n8 VSS 0.28917f
C416 O_QBUF.n9 VSS 2.53404f
C417 O_QBUF.t0 VSS 1.13267f
C418 O_QBUF.t1 VSS 1.12564f
C419 O_QBUF.n10 VSS 1.08943f
C420 O_QBUF.t2 VSS 0.54403f
C421 O_QBUF.t3 VSS 0.53783f
C422 O_QBUF.n11 VSS 0.48153f
C423 O_QBUF.n12 VSS 1.70254f
C424 O_QBUF.n13 VSS 0.78588f
C425 O_QBBUF.n0 VSS 0.13089f
C426 O_QBBUF.n1 VSS 0.14232f
C427 O_QBBUF.n2 VSS 0.14232f
C428 O_QBBUF.n3 VSS 0.13089f
C429 O_QBBUF.n4 VSS 1.1571f
C430 O_QBBUF.n5 VSS 0.13501f
C431 O_QBBUF.n6 VSS 0.14232f
C432 O_QBBUF.n7 VSS 0.12972f
C433 O_QBBUF.n8 VSS 0.30396f
C434 O_QBBUF.n9 VSS 2.67488f
C435 O_QBBUF.t1 VSS 1.19723f
C436 O_QBBUF.t0 VSS 1.18971f
C437 O_QBBUF.n10 VSS 1.16376f
C438 O_QBBUF.t3 VSS 0.5743f
C439 O_QBBUF.t2 VSS 0.56767f
C440 O_QBBUF.n11 VSS 0.51438f
C441 O_QBBUF.n12 VSS 1.90408f
C442 O_QBBUF.n13 VSS 0.85474f
C443 E_QI.n0 VSS 0.63059f
C444 E_QI.n1 VSS 0.45222f
C445 E_QI.n2 VSS 2.3635f
C446 E_QI.t7 VSS 1.3433f
C447 E_QI.t6 VSS 0.33534f
C448 E_QI.t5 VSS 0.33534f
C449 E_QI.n3 VSS 0.96718f
C450 E_QI.n4 VSS 0.47701f
C451 E_QI.t4 VSS 1.33528f
C452 E_QI.n5 VSS 0.57097f
C453 E_QI.t2 VSS 1.34945f
C454 E_QI.t3 VSS 1.34077f
C455 E_QI.n6 VSS 0.51689f
C456 E_QI.n7 VSS 2.04706f
C457 E_QI.t0 VSS 1.34714f
C458 E_QI.t1 VSS 1.33845f
C459 E_QI.n8 VSS 0.52152f
C460 E_QI.n9 VSS 1.16529f
C461 E_QI.t11 VSS 1.34099f
C462 E_QI.t10 VSS 0.33534f
C463 E_QI.t9 VSS 0.33534f
C464 E_QI.n10 VSS 0.96004f
C465 E_QI.n11 VSS 0.48645f
C466 E_QI.t8 VSS 1.33297f
C467 E_QI.n12 VSS 0.83233f
C468 E_QI.n13 VSS 1.61446f
C469 E_QI.n14 VSS 1.78147f
C470 E_QI.n15 VSS 0.8155f
C471 E_QI.n16 VSS 0.40409f
C472 E_QI.n17 VSS 2.91939f
C473 E_QI.n18 VSS 1.02052f
C474 EVEN_DB_BUF.n0 VSS 0.28876f
C475 EVEN_DB_BUF.n1 VSS 0.14273f
C476 EVEN_DB_BUF.n2 VSS 0.15299f
C477 EVEN_DB_BUF.n3 VSS 0.15299f
C478 EVEN_DB_BUF.n4 VSS 0.14459f
C479 EVEN_DB_BUF.n5 VSS 0.28484f
C480 EVEN_DB_BUF.n6 VSS 0.28876f
C481 EVEN_DB_BUF.n7 VSS 0.14273f
C482 EVEN_DB_BUF.n8 VSS 0.15299f
C483 EVEN_DB_BUF.n9 VSS 0.15299f
C484 EVEN_DB_BUF.n10 VSS 0.14459f
C485 EVEN_DB_BUF.n11 VSS 1.61784f
C486 EVEN_DB_BUF.n12 VSS 4.01535f
C487 EVEN_DB_BUF.t11 VSS 1.20055f
C488 EVEN_DB_BUF.t10 VSS 0.26135f
C489 EVEN_DB_BUF.t9 VSS 0.26135f
C490 EVEN_DB_BUF.n13 VSS 0.89757f
C491 EVEN_DB_BUF.n14 VSS 0.45479f
C492 EVEN_DB_BUF.t8 VSS 1.19571f
C493 EVEN_DB_BUF.n15 VSS 0.96829f
C494 EVEN_DB_BUF.t7 VSS 1.20271f
C495 EVEN_DB_BUF.t6 VSS 0.26135f
C496 EVEN_DB_BUF.t5 VSS 0.26135f
C497 EVEN_DB_BUF.n16 VSS 0.90424f
C498 EVEN_DB_BUF.n17 VSS 0.49703f
C499 EVEN_DB_BUF.t4 VSS 0.26135f
C500 EVEN_DB_BUF.t3 VSS 0.26135f
C501 EVEN_DB_BUF.n18 VSS 0.90424f
C502 EVEN_DB_BUF.n19 VSS 0.2084f
C503 EVEN_DB_BUF.t0 VSS 1.20271f
C504 EVEN_DB_BUF.t2 VSS 0.26135f
C505 EVEN_DB_BUF.t1 VSS 0.26135f
C506 EVEN_DB_BUF.n20 VSS 0.90424f
C507 EVEN_DB_BUF.n21 VSS 0.44597f
C508 EVEN_DB_BUF.n22 VSS 0.10213f
C509 EVEN_DB_BUF.n23 VSS 1.79303f
C510 EVEN_DB_BUF.n24 VSS 0.71016f
C511 ODD_DB_BUF.t11 VSS 1.21205f
C512 ODD_DB_BUF.t10 VSS 0.26253f
C513 ODD_DB_BUF.t9 VSS 0.26253f
C514 ODD_DB_BUF.n0 VSS 0.90745f
C515 ODD_DB_BUF.n1 VSS 0.4598f
C516 ODD_DB_BUF.t8 VSS 1.20715f
C517 ODD_DB_BUF.n2 VSS 0.97895f
C518 ODD_DB_BUF.t7 VSS 1.21423f
C519 ODD_DB_BUF.t6 VSS 0.26253f
C520 ODD_DB_BUF.t5 VSS 0.26253f
C521 ODD_DB_BUF.n3 VSS 0.91419f
C522 ODD_DB_BUF.n4 VSS 0.5025f
C523 ODD_DB_BUF.t4 VSS 0.26253f
C524 ODD_DB_BUF.t3 VSS 0.26253f
C525 ODD_DB_BUF.n5 VSS 0.91419f
C526 ODD_DB_BUF.n6 VSS 0.21069f
C527 ODD_DB_BUF.t0 VSS 1.21423f
C528 ODD_DB_BUF.t2 VSS 0.26253f
C529 ODD_DB_BUF.t1 VSS 0.26253f
C530 ODD_DB_BUF.n7 VSS 0.91419f
C531 ODD_DB_BUF.n8 VSS 0.45088f
C532 ODD_DB_BUF.n9 VSS 0.10325f
C533 ODD_DB_BUF.n10 VSS 2.20485f
C534 ODD_DB_BUF.n11 VSS 0.29194f
C535 ODD_DB_BUF.n12 VSS 0.1443f
C536 ODD_DB_BUF.n13 VSS 0.15468f
C537 ODD_DB_BUF.n14 VSS 0.15468f
C538 ODD_DB_BUF.n15 VSS 0.14619f
C539 ODD_DB_BUF.n16 VSS 0.26721f
C540 ODD_DB_BUF.n17 VSS 0.29194f
C541 ODD_DB_BUF.n18 VSS 0.1443f
C542 ODD_DB_BUF.n19 VSS 0.15468f
C543 ODD_DB_BUF.n20 VSS 0.15468f
C544 ODD_DB_BUF.n21 VSS 0.14619f
C545 ODD_DB_BUF.n22 VSS 1.72548f
C546 ODD_DB_BUF.n23 VSS 3.85474f
C547 ODD_DB_BUF.n24 VSS 0.93032f
C548 O_QI.n0 VSS 0.80919f
C549 O_QI.n1 VSS 0.40096f
C550 O_QI.n2 VSS 3.27727f
C551 O_QI.t4 VSS 1.33574f
C552 O_QI.t0 VSS 0.33553f
C553 O_QI.t1 VSS 0.33553f
C554 O_QI.n3 VSS 0.95969f
C555 O_QI.n4 VSS 0.47332f
C556 O_QI.t11 VSS 1.32772f
C557 O_QI.n5 VSS 0.56655f
C558 O_QI.t9 VSS 1.34499f
C559 O_QI.t10 VSS 1.33638f
C560 O_QI.n6 VSS 0.51289f
C561 O_QI.n7 VSS 2.03122f
C562 O_QI.t7 VSS 1.3427f
C563 O_QI.t8 VSS 1.33408f
C564 O_QI.n8 VSS 0.51748f
C565 O_QI.n9 VSS 1.04146f
C566 O_QI.t2 VSS 1.33345f
C567 O_QI.t5 VSS 0.33553f
C568 O_QI.t6 VSS 0.33553f
C569 O_QI.n10 VSS 0.95261f
C570 O_QI.n11 VSS 0.48268f
C571 O_QI.t3 VSS 1.32543f
C572 O_QI.n12 VSS 0.91539f
C573 O_QI.n13 VSS 1.62727f
C574 O_QI.n14 VSS 2.164f
C575 O_QI.n15 VSS 0.58327f
C576 O_QI.n16 VSS 0.46862f
C577 O_QI.n17 VSS 2.16895f
C578 O_QI.n18 VSS 0.46743f
C579 E_PSET_TAIL.t11 VSS 2.04555f
C580 E_PSET_TAIL.t10 VSS 0.43538f
C581 E_PSET_TAIL.t9 VSS 0.43538f
C582 E_PSET_TAIL.n0 VSS 1.54688f
C583 E_PSET_TAIL.n1 VSS 0.85027f
C584 E_PSET_TAIL.t8 VSS 0.43538f
C585 E_PSET_TAIL.t7 VSS 0.43538f
C586 E_PSET_TAIL.n2 VSS 1.54688f
C587 E_PSET_TAIL.n3 VSS 0.44386f
C588 E_PSET_TAIL.t6 VSS 0.43538f
C589 E_PSET_TAIL.t5 VSS 0.43538f
C590 E_PSET_TAIL.n4 VSS 1.54688f
C591 E_PSET_TAIL.n5 VSS 0.44386f
C592 E_PSET_TAIL.t4 VSS 2.02905f
C593 E_PSET_TAIL.n6 VSS 2.2193f
C594 E_PSET_TAIL.t3 VSS 0.45018f
C595 E_PSET_TAIL.t1 VSS 0.44734f
C596 E_PSET_TAIL.n7 VSS 1.55899f
C597 E_PSET_TAIL.t2 VSS 0.44734f
C598 E_PSET_TAIL.t0 VSS 0.44734f
C599 E_PSET_TAIL.n8 VSS 1.54688f
C600 E_PSET_TAIL.n9 VSS 2.2126f
C601 E_PSET_TAIL.n10 VSS 3.81367f
C602 O_PSET_TAIL.t1 VSS 0.43132f
C603 O_PSET_TAIL.t11 VSS 0.43132f
C604 O_PSET_TAIL.n0 VSS 1.46688f
C605 O_PSET_TAIL.t2 VSS 0.4342f
C606 O_PSET_TAIL.t0 VSS 0.43132f
C607 O_PSET_TAIL.n1 VSS 1.45549f
C608 O_PSET_TAIL.n2 VSS 2.74646f
C609 O_PSET_TAIL.t10 VSS 1.94519f
C610 O_PSET_TAIL.t9 VSS 0.42977f
C611 O_PSET_TAIL.t8 VSS 0.42977f
C612 O_PSET_TAIL.n3 VSS 1.45549f
C613 O_PSET_TAIL.n4 VSS 0.80004f
C614 O_PSET_TAIL.t7 VSS 0.42977f
C615 O_PSET_TAIL.t6 VSS 0.42977f
C616 O_PSET_TAIL.n5 VSS 1.45549f
C617 O_PSET_TAIL.n6 VSS 0.41764f
C618 O_PSET_TAIL.t5 VSS 0.42977f
C619 O_PSET_TAIL.t4 VSS 0.42977f
C620 O_PSET_TAIL.n7 VSS 1.45549f
C621 O_PSET_TAIL.n8 VSS 0.41764f
C622 O_PSET_TAIL.t3 VSS 1.92928f
C623 O_PSET_TAIL.n9 VSS 1.58693f
C624 O_PSET_TAIL.n10 VSS 4.05229f
C625 E_SET_TAIL.t0 VSS 0.3085f
C626 E_SET_TAIL.t1 VSS 0.3085f
C627 E_SET_TAIL.n0 VSS 0.69793f
C628 E_SET_TAIL.t2 VSS 0.31183f
C629 E_SET_TAIL.t3 VSS 0.3085f
C630 E_SET_TAIL.n1 VSS 0.69236f
C631 E_SET_TAIL.n2 VSS 0.55269f
C632 E_SET_TAIL.t11 VSS 0.89951f
C633 E_SET_TAIL.t10 VSS 0.17553f
C634 E_SET_TAIL.t9 VSS 0.17553f
C635 E_SET_TAIL.n3 VSS 0.69236f
C636 E_SET_TAIL.n4 VSS 0.3902f
C637 E_SET_TAIL.t8 VSS 0.17553f
C638 E_SET_TAIL.t7 VSS 0.17553f
C639 E_SET_TAIL.n5 VSS 0.69236f
C640 E_SET_TAIL.n6 VSS 0.20528f
C641 E_SET_TAIL.t4 VSS 0.89951f
C642 E_SET_TAIL.t6 VSS 0.17553f
C643 E_SET_TAIL.t5 VSS 0.17553f
C644 E_SET_TAIL.n7 VSS 0.69236f
C645 E_SET_TAIL.n8 VSS 0.59761f
C646 E_SET_TAIL.n9 VSS 1.04754f
C647 O_SET_TAIL.t11 VSS 0.87733f
C648 O_SET_TAIL.t10 VSS 0.17413f
C649 O_SET_TAIL.t9 VSS 0.17413f
C650 O_SET_TAIL.n0 VSS 0.67242f
C651 O_SET_TAIL.n1 VSS 0.37897f
C652 O_SET_TAIL.t8 VSS 0.17413f
C653 O_SET_TAIL.t7 VSS 0.17413f
C654 O_SET_TAIL.n2 VSS 0.67242f
C655 O_SET_TAIL.n3 VSS 0.19937f
C656 O_SET_TAIL.t4 VSS 0.87733f
C657 O_SET_TAIL.t6 VSS 0.17413f
C658 O_SET_TAIL.t5 VSS 0.17413f
C659 O_SET_TAIL.n4 VSS 0.67242f
C660 O_SET_TAIL.n5 VSS 0.55941f
C661 O_SET_TAIL.t0 VSS 0.30066f
C662 O_SET_TAIL.t1 VSS 0.30066f
C663 O_SET_TAIL.n6 VSS 0.67784f
C664 O_SET_TAIL.t2 VSS 0.30392f
C665 O_SET_TAIL.t3 VSS 0.30066f
C666 O_SET_TAIL.n7 VSS 0.67242f
C667 O_SET_TAIL.n8 VSS 0.49654f
C668 O_SET_TAIL.n9 VSS 0.70815f
C669 E_RST_TAIL.t11 VSS 0.69702f
C670 E_RST_TAIL.t10 VSS 0.14385f
C671 E_RST_TAIL.t9 VSS 0.14385f
C672 E_RST_TAIL.n0 VSS 0.52959f
C673 E_RST_TAIL.n1 VSS 0.29847f
C674 E_RST_TAIL.t8 VSS 0.14385f
C675 E_RST_TAIL.t7 VSS 0.14385f
C676 E_RST_TAIL.n2 VSS 0.52959f
C677 E_RST_TAIL.n3 VSS 0.15702f
C678 E_RST_TAIL.t6 VSS 0.14385f
C679 E_RST_TAIL.t5 VSS 0.14385f
C680 E_RST_TAIL.n4 VSS 0.52959f
C681 E_RST_TAIL.n5 VSS 0.12689f
C682 E_RST_TAIL.t4 VSS 0.69495f
C683 E_RST_TAIL.n6 VSS 0.39288f
C684 E_RST_TAIL.t1 VSS 0.25157f
C685 E_RST_TAIL.t3 VSS 0.25157f
C686 E_RST_TAIL.n7 VSS 0.53385f
C687 E_RST_TAIL.t2 VSS 0.25441f
C688 E_RST_TAIL.t0 VSS 0.25157f
C689 E_RST_TAIL.n8 VSS 0.52959f
C690 E_RST_TAIL.n9 VSS 0.74399f
C691 E_RST_TAIL.n10 VSS 0.79603f
C692 O_RST_TAIL.t3 VSS 0.26282f
C693 O_RST_TAIL.t1 VSS 0.26282f
C694 O_RST_TAIL.n0 VSS 0.58367f
C695 O_RST_TAIL.t0 VSS 0.2657f
C696 O_RST_TAIL.t2 VSS 0.26282f
C697 O_RST_TAIL.n1 VSS 0.57901f
C698 O_RST_TAIL.n2 VSS 1.07614f
C699 O_RST_TAIL.t11 VSS 0.76075f
C700 O_RST_TAIL.t10 VSS 0.15595f
C701 O_RST_TAIL.t9 VSS 0.15595f
C702 O_RST_TAIL.n3 VSS 0.57901f
C703 O_RST_TAIL.n4 VSS 0.32632f
C704 O_RST_TAIL.t8 VSS 0.15595f
C705 O_RST_TAIL.t7 VSS 0.15595f
C706 O_RST_TAIL.n5 VSS 0.57901f
C707 O_RST_TAIL.n6 VSS 0.17168f
C708 O_RST_TAIL.t6 VSS 0.15595f
C709 O_RST_TAIL.t5 VSS 0.15595f
C710 O_RST_TAIL.n7 VSS 0.57901f
C711 O_RST_TAIL.n8 VSS 0.13874f
C712 O_RST_TAIL.t4 VSS 0.75845f
C713 O_RST_TAIL.n9 VSS 0.45887f
C714 O_RST_TAIL.n10 VSS 1.41565f
C715 VSS.t85 VSS 0.13279f
C716 VSS.t76 VSS 0.13279f
C717 VSS.t74 VSS 0.13533f
C718 VSS.t61 VSS 0.08715f
C719 VSS.t68 VSS 0.0872f
C720 VSS.t34 VSS 0.1054f
C721 VSS.t32 VSS 0.10342f
C722 VSS.t30 VSS 0.10342f
C723 VSS.t28 VSS 0.1054f
C724 VSS.t44 VSS 0.08832f
C725 VSS.t46 VSS 0.08666f
C726 VSS.t50 VSS 0.08666f
C727 VSS.t48 VSS 0.08832f
C728 VSS.t126 VSS 0.04156f
C729 VSS.t124 VSS 0.04078f
C730 VSS.t12 VSS 0.15749f
C731 VSS.t13 VSS 0.15749f
C732 VSS.t119 VSS 0.04078f
C733 VSS.t116 VSS 0.04156f
C734 VSS.t117 VSS 0.04078f
C735 VSS.t120 VSS 0.04078f
C736 VSS.t121 VSS 0.04078f
C737 VSS.t114 VSS 0.04078f
C738 VSS.t24 VSS 0.12632f
C739 VSS.t22 VSS 0.12632f
C740 VSS.t72 VSS 0.12874f
C741 VSS.t135 VSS 0.04078f
C742 VSS.t132 VSS 0.04078f
C743 VSS.t130 VSS 0.04078f
C744 VSS.t128 VSS 0.04156f
C745 VSS.t131 VSS 0.04078f
C746 VSS.t122 VSS 0.04078f
C747 VSS.t81 VSS 0.16186f
C748 VSS.t60 VSS 0.16186f
C749 VSS.t137 VSS 0.04078f
C750 VSS.t134 VSS 0.04078f
C751 VSS.t5 VSS 0.0848f
C752 VSS.t7 VSS 0.08484f
C753 VSS.t87 VSS 0.08737f
C754 VSS.t89 VSS 0.08741f
C755 VSS.t3 VSS 0.12931f
C756 VSS.t63 VSS 0.13179f
C757 VSS.t83 VSS 0.12931f
C758 VSS.t9 VSS 0.16061f
C759 VSS.t11 VSS 0.16061f
C760 VSS.t106 VSS 0.04326f
C761 VSS.t91 VSS 0.04409f
C762 VSS.t104 VSS 0.04326f
C763 VSS.t107 VSS 0.04326f
C764 VSS.t109 VSS 0.04326f
C765 VSS.t108 VSS 0.04326f
C766 VSS.t113 VSS 0.04326f
C767 VSS.t111 VSS 0.04326f
C768 VSS.t93 VSS 0.04409f
C769 VSS.t103 VSS 0.04326f
C770 VSS.t64 VSS 0.16226f
C771 VSS.t65 VSS 0.16226f
C772 VSS.t97 VSS 0.04326f
C773 VSS.t95 VSS 0.04409f
C774 VSS.t99 VSS 0.04326f
C775 VSS.t98 VSS 0.04326f
C776 VSS.t101 VSS 0.04326f
C777 VSS.t100 VSS 0.04326f
C778 VSS.t42 VSS 0.08757f
C779 VSS.t40 VSS 0.08592f
C780 VSS.t38 VSS 0.08592f
C781 VSS.t36 VSS 0.08757f
C782 VSS.t66 VSS 0.08648f
C783 VSS.t67 VSS 0.08652f
C784 VSS.t58 VSS 0.1037f
C785 VSS.t52 VSS 0.10175f
C786 VSS.t56 VSS 0.10175f
C787 VSS.t54 VSS 0.1037f
C788 VSS.t19 VSS 0.13813f
C789 VSS.t139 VSS 0.13813f
C790 VSS.t70 VSS 0.14078f
C791 VDD.n0 VSS 0.34521f
C792 VDD.n1 VSS 0.11173f
C793 VDD.n2 VSS 0.1632f
C794 VDD.n3 VSS 0.1561f
C795 VDD.t24 VSS 1.04069f
C796 VDD.n4 VSS 0.1561f
C797 VDD.n5 VSS 0.1632f
C798 VDD.n6 VSS 0.16637f
C799 VDD.n7 VSS 0.1632f
C800 VDD.n8 VSS 0.1561f
C801 VDD.t110 VSS 3.95462f
C802 VDD.t26 VSS 0.83255f
C803 VDD.t28 VSS 0.83255f
C804 VDD.t32 VSS 0.83255f
C805 VDD.t30 VSS 0.83255f
C806 VDD.t34 VSS 0.83255f
C807 VDD.t36 VSS 0.83255f
C808 VDD.t38 VSS 2.08138f
C809 VDD.n9 VSS 0.43916f
C810 VDD.t120 VSS 0.62441f
C811 VDD.n10 VSS 0.1561f
C812 VDD.n11 VSS 0.1632f
C813 VDD.n12 VSS 0.16637f
C814 VDD.n13 VSS 0.1632f
C815 VDD.n14 VSS 0.1561f
C816 VDD.t116 VSS 1.04069f
C817 VDD.n15 VSS 0.1561f
C818 VDD.n16 VSS 0.1632f
C819 VDD.n17 VSS 0.16637f
C820 VDD.n18 VSS 0.1632f
C821 VDD.n19 VSS 0.1561f
C822 VDD.t0 VSS 0.62441f
C823 VDD.n20 VSS 0.70472f
C824 VDD.t68 VSS 1.04069f
C825 VDD.n21 VSS 0.1561f
C826 VDD.n22 VSS 0.1632f
C827 VDD.n23 VSS 0.13965f
C828 VDD.n24 VSS 0.1632f
C829 VDD.n25 VSS 0.1561f
C830 VDD.n26 VSS 7.96679f
C831 VDD.n27 VSS 5.99899f
C832 VDD.n28 VSS 2.49765f
C833 VDD.t162 VSS 0.83255f
C834 VDD.t18 VSS 0.83255f
C835 VDD.t160 VSS 0.83255f
C836 VDD.t112 VSS 3.95462f
C837 VDD.t66 VSS 0.83255f
C838 VDD.t64 VSS 0.83255f
C839 VDD.t62 VSS 0.83255f
C840 VDD.t72 VSS 0.83255f
C841 VDD.t74 VSS 0.83255f
C842 VDD.t70 VSS 0.83255f
C843 VDD.t76 VSS 2.08138f
C844 VDD.n29 VSS 3.6119f
C845 VDD.t96 VSS 2.08138f
C846 VDD.t98 VSS 0.83255f
C847 VDD.t101 VSS 0.83255f
C848 VDD.t11 VSS 0.83255f
C849 VDD.t9 VSS 0.83255f
C850 VDD.t104 VSS 0.83255f
C851 VDD.t106 VSS 0.83255f
C852 VDD.t108 VSS 1.04069f
C853 VDD.n30 VSS 4.16276f
C854 VDD.n31 VSS 0.1561f
C855 VDD.n32 VSS 0.1632f
C856 VDD.n33 VSS 0.4504f
C857 VDD.n34 VSS 0.16637f
C858 VDD.n35 VSS 0.16637f
C859 VDD.n36 VSS 0.1632f
C860 VDD.n37 VSS 0.1561f
C861 VDD.n38 VSS 4.16276f
C862 VDD.t17 VSS 3.95462f
C863 VDD.t6 VSS 0.83255f
C864 VDD.t4 VSS 0.83255f
C865 VDD.t5 VSS 0.83255f
C866 VDD.n39 VSS 2.49765f
C867 VDD.t52 VSS 0.83255f
C868 VDD.t43 VSS 0.83255f
C869 VDD.t54 VSS 2.08138f
C870 VDD.n40 VSS 4.02818f
C871 VDD.n41 VSS 0.43916f
C872 VDD.n42 VSS 0.43916f
C873 VDD.n43 VSS 0.69797f
C874 VDD.t114 VSS 4.16276f
C875 VDD.n44 VSS 5.41158f
C876 VDD.t20 VSS 1.87324f
C877 VDD.t78 VSS 0.83255f
C878 VDD.t158 VSS 0.83255f
C879 VDD.t22 VSS 1.45697f
C880 VDD.t46 VSS 1.45697f
C881 VDD.t40 VSS 0.83255f
C882 VDD.t49 VSS 0.83255f
C883 VDD.t2 VSS 0.62441f
C884 VDD.n45 VSS 0.41628f
C885 VDD.n46 VSS 0.1561f
C886 VDD.n47 VSS 0.1632f
C887 VDD.n48 VSS 0.16637f
C888 VDD.n49 VSS 0.16637f
C889 VDD.n50 VSS 0.16637f
C890 VDD.n51 VSS 0.1632f
C891 VDD.n52 VSS 0.1561f
C892 VDD.n53 VSS 6.036f
C893 VDD.n54 VSS 10.4069f
C894 VDD.t145 VSS 0.83255f
C895 VDD.t147 VSS 0.83255f
C896 VDD.t149 VSS 1.45697f
C897 VDD.t7 VSS 1.45697f
C898 VDD.t131 VSS 0.83255f
C899 VDD.t133 VSS 0.83255f
C900 VDD.t124 VSS 1.87324f
C901 VDD.n55 VSS 5.41158f
C902 VDD.t128 VSS 4.16276f
C903 VDD.n56 VSS 0.69797f
C904 VDD.t126 VSS 1.04069f
C905 VDD.n57 VSS 6.036f
C906 VDD.n58 VSS 0.1561f
C907 VDD.n59 VSS 0.1632f
C908 VDD.n60 VSS 0.16637f
C909 VDD.n61 VSS 0.16637f
C910 VDD.n62 VSS 0.16637f
C911 VDD.n63 VSS 0.1632f
C912 VDD.n64 VSS 0.1561f
C913 VDD.n65 VSS 0.41628f
C914 VDD.t142 VSS 0.62441f
C915 VDD.t140 VSS 0.83255f
C916 VDD.t138 VSS 0.83255f
C917 VDD.t135 VSS 2.08138f
C918 VDD.t15 VSS 0.83255f
C919 VDD.t13 VSS 0.83255f
C920 VDD.t130 VSS 0.83255f
C921 VDD.n66 VSS 2.49765f
C922 VDD.n67 VSS 4.02818f
C923 VDD.n68 VSS 0.43916f
C924 VDD.n69 VSS 0.43257f
C925 VDD.n70 VSS 3.6119f
C926 VDD.t84 VSS 2.08138f
C927 VDD.t80 VSS 0.83255f
C928 VDD.t86 VSS 0.83255f
C929 VDD.t90 VSS 0.83255f
C930 VDD.t88 VSS 0.83255f
C931 VDD.t92 VSS 0.83255f
C932 VDD.t82 VSS 0.83255f
C933 VDD.t94 VSS 1.04069f
C934 VDD.n71 VSS 4.16276f
C935 VDD.n72 VSS 0.1561f
C936 VDD.n73 VSS 0.1632f
C937 VDD.n74 VSS 0.16637f
C938 VDD.n75 VSS 0.16637f
C939 VDD.n76 VSS 0.16637f
C940 VDD.n77 VSS 0.1632f
C941 VDD.n78 VSS 0.1561f
C942 VDD.n79 VSS 4.16276f
C943 VDD.t166 VSS 3.95462f
C944 VDD.t118 VSS 0.83255f
C945 VDD.t168 VSS 0.83255f
C946 VDD.t164 VSS 0.83255f
C947 VDD.n80 VSS 2.49765f
C948 VDD.n81 VSS 5.97912f
C949 VDD.n82 VSS 7.95698f
C950 VDD.n83 VSS 0.13387f
C951 VDD.n84 VSS 0.20659f
C952 VDD.n85 VSS 0.09771f
C953 VDD.t121 VSS 0.1799f
C954 VDD.t170 VSS 0.1799f
C955 VDD.n86 VSS 0.14712f
C956 VDD.t132 VSS 0.14436f
C957 VDD.t8 VSS 0.14678f
C958 VDD.n87 VSS 0.0941f
C959 VDD.t125 VSS 0.14678f
C960 VDD.t134 VSS 0.14436f
C961 VDD.n88 VSS 0.09337f
C962 VDD.n89 VSS 0.04697f
C963 VDD.n90 VSS 0.24104f
C964 VDD.t151 VSS 0.15458f
C965 VDD.t136 VSS 0.15458f
C966 VDD.n91 VSS 0.0941f
C967 VDD.t153 VSS 0.15458f
C968 VDD.t152 VSS 0.15458f
C969 VDD.n92 VSS 0.09337f
C970 VDD.n93 VSS 0.04732f
C971 VDD.t155 VSS 0.15458f
C972 VDD.t154 VSS 0.15458f
C973 VDD.n94 VSS 0.09337f
C974 VDD.n95 VSS 0.02679f
C975 VDD.t157 VSS 0.1572f
C976 VDD.t156 VSS 0.15458f
C977 VDD.n96 VSS 0.09337f
C978 VDD.n97 VSS 0.02679f
C979 VDD.n98 VSS 0.08263f
C980 VDD.n99 VSS 0.24114f
C981 VDD.n100 VSS 0.14447f
C982 VDD.t115 VSS 0.18028f
C983 VDD.t117 VSS 0.18031f
C984 VDD.n101 VSS 0.17028f
C985 VDD.t23 VSS 0.14983f
C986 VDD.t159 VSS 0.14735f
C987 VDD.n102 VSS 0.0941f
C988 VDD.t79 VSS 0.14735f
C989 VDD.t21 VSS 0.14983f
C990 VDD.n103 VSS 0.09337f
C991 VDD.n104 VSS 0.09625f
C992 VDD.n105 VSS 0.20256f
C993 VDD.t1 VSS 0.17865f
C994 VDD.t3 VSS 0.17865f
C995 VDD.n106 VSS 0.14712f
C996 VDD.t161 VSS 0.15617f
C997 VDD.t113 VSS 0.15882f
C998 VDD.n107 VSS 0.0941f
C999 VDD.t163 VSS 0.15882f
C1000 VDD.t19 VSS 0.15617f
C1001 VDD.n108 VSS 0.09337f
C1002 VDD.n109 VSS 0.15713f
C1003 VDD.n110 VSS 0.44212f
C1004 VDD.t99 VSS 0.11979f
C1005 VDD.t97 VSS 0.12174f
C1006 VDD.n111 VSS 0.0941f
C1007 VDD.t100 VSS 0.11979f
C1008 VDD.t102 VSS 0.11979f
C1009 VDD.n112 VSS 0.09337f
C1010 VDD.n113 VSS 0.04732f
C1011 VDD.t105 VSS 0.11979f
C1012 VDD.t103 VSS 0.11979f
C1013 VDD.n114 VSS 0.09337f
C1014 VDD.n115 VSS 0.02679f
C1015 VDD.t109 VSS 0.12174f
C1016 VDD.t107 VSS 0.11979f
C1017 VDD.n116 VSS 0.09337f
C1018 VDD.n117 VSS 0.27079f
C1019 VDD.t10 VSS 0.17863f
C1020 VDD.t12 VSS 0.17866f
C1021 VDD.n118 VSS 0.11521f
C1022 VDD.n119 VSS 0.33422f
C1023 VDD.n120 VSS 0.18138f
C1024 VDD.n121 VSS 0.29963f
C1025 VDD.t77 VSS 0.1056f
C1026 VDD.t71 VSS 0.10396f
C1027 VDD.n122 VSS 0.09337f
C1028 VDD.n123 VSS 0.23125f
C1029 VDD.t67 VSS 0.10396f
C1030 VDD.t69 VSS 0.1056f
C1031 VDD.n124 VSS 0.0941f
C1032 VDD.t63 VSS 0.10396f
C1033 VDD.t65 VSS 0.10396f
C1034 VDD.n125 VSS 0.09337f
C1035 VDD.n126 VSS 0.04732f
C1036 VDD.t75 VSS 0.10396f
C1037 VDD.t73 VSS 0.10396f
C1038 VDD.n127 VSS 0.09337f
C1039 VDD.n128 VSS 0.02152f
C1040 VDD.n129 VSS 0.22581f
C1041 VDD.n130 VSS 0.28381f
C1042 VDD.t122 VSS 0.1803f
C1043 VDD.t123 VSS 0.1803f
C1044 VDD.n131 VSS 0.31256f
C1045 VDD.n132 VSS 0.39579f
C1046 VDD.n133 VSS 0.23974f
C1047 VDD.t56 VSS 0.16662f
C1048 VDD.t47 VSS 0.16662f
C1049 VDD.n134 VSS 0.0941f
C1050 VDD.t42 VSS 0.16662f
C1051 VDD.t57 VSS 0.16662f
C1052 VDD.n135 VSS 0.09337f
C1053 VDD.n136 VSS 0.04732f
C1054 VDD.t59 VSS 0.16662f
C1055 VDD.t58 VSS 0.16662f
C1056 VDD.n137 VSS 0.09337f
C1057 VDD.n138 VSS 0.02679f
C1058 VDD.t61 VSS 0.16947f
C1059 VDD.t60 VSS 0.16662f
C1060 VDD.n139 VSS 0.09337f
C1061 VDD.n140 VSS 0.02679f
C1062 VDD.n141 VSS 0.21849f
C1063 VDD.n142 VSS 0.24114f
C1064 VDD.n143 VSS 0.1868f
C1065 VDD.t55 VSS 0.16947f
C1066 VDD.t44 VSS 0.16662f
C1067 VDD.n144 VSS 0.09337f
C1068 VDD.n145 VSS 0.04172f
C1069 VDD.t53 VSS 0.16662f
C1070 VDD.t51 VSS 0.16662f
C1071 VDD.n146 VSS 0.09337f
C1072 VDD.n147 VSS 0.02679f
C1073 VDD.t45 VSS 0.16662f
C1074 VDD.t50 VSS 0.16662f
C1075 VDD.n148 VSS 0.09337f
C1076 VDD.n149 VSS 0.02679f
C1077 VDD.t41 VSS 0.16662f
C1078 VDD.t48 VSS 0.16662f
C1079 VDD.n150 VSS 0.09337f
C1080 VDD.n151 VSS 0.12541f
C1081 VDD.n152 VSS 0.13419f
C1082 VDD.n153 VSS 0.30002f
C1083 VDD.t127 VSS 0.17552f
C1084 VDD.t129 VSS 0.17555f
C1085 VDD.n154 VSS 0.25241f
C1086 VDD.n155 VSS 0.45226f
C1087 VDD.n156 VSS 0.15238f
C1088 VDD.t139 VSS 0.15458f
C1089 VDD.t137 VSS 0.15458f
C1090 VDD.n157 VSS 0.0941f
C1091 VDD.t143 VSS 0.15458f
C1092 VDD.t141 VSS 0.15458f
C1093 VDD.n158 VSS 0.09337f
C1094 VDD.n159 VSS 0.04732f
C1095 VDD.t146 VSS 0.15458f
C1096 VDD.t144 VSS 0.15458f
C1097 VDD.n160 VSS 0.09337f
C1098 VDD.n161 VSS 0.02679f
C1099 VDD.t150 VSS 0.1572f
C1100 VDD.t148 VSS 0.15458f
C1101 VDD.n162 VSS 0.09337f
C1102 VDD.n163 VSS 0.02679f
C1103 VDD.n164 VSS 0.16431f
C1104 VDD.n165 VSS 0.18617f
C1105 VDD.n166 VSS 0.1181f
C1106 VDD.t14 VSS 0.17553f
C1107 VDD.t16 VSS 0.17553f
C1108 VDD.n167 VSS 0.31256f
C1109 VDD.n168 VSS 0.44852f
C1110 VDD.n169 VSS 0.31017f
C1111 VDD.t95 VSS 0.10636f
C1112 VDD.t83 VSS 0.1047f
C1113 VDD.n170 VSS 0.09337f
C1114 VDD.n171 VSS 0.23125f
C1115 VDD.t81 VSS 0.1047f
C1116 VDD.t85 VSS 0.10636f
C1117 VDD.n172 VSS 0.0941f
C1118 VDD.t91 VSS 0.1047f
C1119 VDD.t87 VSS 0.1047f
C1120 VDD.n173 VSS 0.09337f
C1121 VDD.n174 VSS 0.04732f
C1122 VDD.t93 VSS 0.1047f
C1123 VDD.t89 VSS 0.1047f
C1124 VDD.n175 VSS 0.09337f
C1125 VDD.n176 VSS 0.02152f
C1126 VDD.n177 VSS 0.22581f
C1127 VDD.n178 VSS 0.28908f
C1128 VDD.n179 VSS 0.29018f
C1129 VDD.t27 VSS 0.12146f
C1130 VDD.t25 VSS 0.12344f
C1131 VDD.n180 VSS 0.0941f
C1132 VDD.t33 VSS 0.12146f
C1133 VDD.t29 VSS 0.12146f
C1134 VDD.n181 VSS 0.09337f
C1135 VDD.n182 VSS 0.04732f
C1136 VDD.t35 VSS 0.12146f
C1137 VDD.t31 VSS 0.12146f
C1138 VDD.n183 VSS 0.09337f
C1139 VDD.n184 VSS 0.02679f
C1140 VDD.t39 VSS 0.12344f
C1141 VDD.t37 VSS 0.12146f
C1142 VDD.n185 VSS 0.09337f
C1143 VDD.n186 VSS 0.27079f
C1144 VDD.t171 VSS 0.17988f
C1145 VDD.t111 VSS 0.17992f
C1146 VDD.n187 VSS 0.11521f
C1147 VDD.n188 VSS 0.33422f
C1148 VDD.n189 VSS 0.18665f
C1149 VDD.t169 VSS 0.15082f
C1150 VDD.t165 VSS 0.15337f
C1151 VDD.n190 VSS 0.0941f
C1152 VDD.t167 VSS 0.15337f
C1153 VDD.t119 VSS 0.15082f
C1154 VDD.n191 VSS 0.09337f
C1155 VDD.n192 VSS 0.1432f
C1156 VDD.n193 VSS 0.26668f
C1157 VDD.n194 VSS 0.03676f
C1158 EVEN_CAPTURE_CLKB.n0 VSS 0.09122f
C1159 EVEN_CAPTURE_CLKB.n1 VSS 0.09122f
C1160 EVEN_CAPTURE_CLKB.n2 VSS 0.09122f
C1161 EVEN_CAPTURE_CLKB.n3 VSS 0.09122f
C1162 EVEN_CAPTURE_CLKB.n4 VSS 0.26551f
C1163 EVEN_CAPTURE_CLKB.n5 VSS 0.13124f
C1164 EVEN_CAPTURE_CLKB.n6 VSS 0.14067f
C1165 EVEN_CAPTURE_CLKB.n7 VSS 0.14067f
C1166 EVEN_CAPTURE_CLKB.n8 VSS 0.14067f
C1167 EVEN_CAPTURE_CLKB.n9 VSS 0.14067f
C1168 EVEN_CAPTURE_CLKB.n10 VSS 0.14067f
C1169 EVEN_CAPTURE_CLKB.n11 VSS 0.14067f
C1170 EVEN_CAPTURE_CLKB.n12 VSS 0.13295f
C1171 EVEN_CAPTURE_CLKB.n13 VSS 0.57924f
C1172 EVEN_CAPTURE_CLKB.n14 VSS 0.09122f
C1173 EVEN_CAPTURE_CLKB.n15 VSS 0.14067f
C1174 EVEN_CAPTURE_CLKB.n16 VSS 0.26551f
C1175 EVEN_CAPTURE_CLKB.n17 VSS 0.13124f
C1176 EVEN_CAPTURE_CLKB.n18 VSS 0.14067f
C1177 EVEN_CAPTURE_CLKB.n19 VSS 0.14067f
C1178 EVEN_CAPTURE_CLKB.n20 VSS 0.14067f
C1179 EVEN_CAPTURE_CLKB.n21 VSS 0.09122f
C1180 EVEN_CAPTURE_CLKB.n22 VSS 0.09122f
C1181 EVEN_CAPTURE_CLKB.n23 VSS 0.09122f
C1182 EVEN_CAPTURE_CLKB.n24 VSS 0.14067f
C1183 EVEN_CAPTURE_CLKB.n25 VSS 0.14067f
C1184 EVEN_CAPTURE_CLKB.n26 VSS 0.13295f
C1185 EVEN_CAPTURE_CLKB.n27 VSS 0.23336f
C1186 EVEN_CAPTURE_CLKB.n28 VSS 4.3039f
C1187 ODD_CAPTURE_CLKB.n0 VSS 0.09927f
C1188 ODD_CAPTURE_CLKB.n1 VSS 0.09927f
C1189 ODD_CAPTURE_CLKB.n2 VSS 0.09927f
C1190 ODD_CAPTURE_CLKB.n3 VSS 0.09927f
C1191 ODD_CAPTURE_CLKB.n4 VSS 0.28893f
C1192 ODD_CAPTURE_CLKB.n5 VSS 0.14281f
C1193 ODD_CAPTURE_CLKB.n6 VSS 0.15308f
C1194 ODD_CAPTURE_CLKB.n7 VSS 0.15308f
C1195 ODD_CAPTURE_CLKB.n8 VSS 0.15308f
C1196 ODD_CAPTURE_CLKB.n9 VSS 0.15308f
C1197 ODD_CAPTURE_CLKB.n10 VSS 0.15308f
C1198 ODD_CAPTURE_CLKB.n11 VSS 0.15308f
C1199 ODD_CAPTURE_CLKB.n12 VSS 0.14468f
C1200 ODD_CAPTURE_CLKB.n13 VSS 0.63032f
C1201 ODD_CAPTURE_CLKB.n14 VSS 0.09927f
C1202 ODD_CAPTURE_CLKB.n15 VSS 0.15308f
C1203 ODD_CAPTURE_CLKB.n16 VSS 0.28893f
C1204 ODD_CAPTURE_CLKB.n17 VSS 0.14281f
C1205 ODD_CAPTURE_CLKB.n18 VSS 0.15308f
C1206 ODD_CAPTURE_CLKB.n19 VSS 0.15308f
C1207 ODD_CAPTURE_CLKB.n20 VSS 0.15308f
C1208 ODD_CAPTURE_CLKB.n21 VSS 0.09927f
C1209 ODD_CAPTURE_CLKB.n22 VSS 0.09927f
C1210 ODD_CAPTURE_CLKB.n23 VSS 0.09927f
C1211 ODD_CAPTURE_CLKB.n24 VSS 0.15308f
C1212 ODD_CAPTURE_CLKB.n25 VSS 0.15308f
C1213 ODD_CAPTURE_CLKB.n26 VSS 0.14468f
C1214 ODD_CAPTURE_CLKB.n27 VSS 0.25394f
C1215 ODD_CAPTURE_CLKB.n28 VSS 4.30449f
C1216 EVEN_Q.t5 VSS 1.30833f
C1217 EVEN_Q.t0 VSS 0.31666f
C1218 EVEN_Q.t6 VSS 0.31666f
C1219 EVEN_Q.n0 VSS 0.95179f
C1220 EVEN_Q.n1 VSS 0.46942f
C1221 EVEN_Q.t4 VSS 1.30323f
C1222 EVEN_Q.n2 VSS 1.50424f
C1223 EVEN_Q.t3 VSS 0.31666f
C1224 EVEN_Q.t2 VSS 0.31666f
C1225 EVEN_Q.n3 VSS 0.94983f
C1226 EVEN_Q.t1 VSS 1.29902f
C1227 EVEN_Q.n4 VSS 0.478f
C1228 EVEN_Q.n5 VSS 2.99553f
C1229 EVEN_QB.t4 VSS 1.23849f
C1230 EVEN_QB.t6 VSS 0.30028f
C1231 EVEN_QB.t5 VSS 0.30028f
C1232 EVEN_QB.n0 VSS 0.90047f
C1233 EVEN_QB.n1 VSS 0.44411f
C1234 EVEN_QB.t0 VSS 1.23367f
C1235 EVEN_QB.n2 VSS 1.42314f
C1236 EVEN_QB.t2 VSS 0.30028f
C1237 EVEN_QB.t1 VSS 0.30028f
C1238 EVEN_QB.n3 VSS 0.89862f
C1239 EVEN_QB.t3 VSS 1.22968f
C1240 EVEN_QB.n4 VSS 0.45223f
C1241 EVEN_QB.n5 VSS 4.71698f
C1242 ODD_QB.t2 VSS 1.12327f
C1243 ODD_QB.t6 VSS 0.28473f
C1244 ODD_QB.t3 VSS 0.28473f
C1245 ODD_QB.n0 VSS 0.8045f
C1246 ODD_QB.n1 VSS 0.39678f
C1247 ODD_QB.t1 VSS 1.11896f
C1248 ODD_QB.n2 VSS 1.21079f
C1249 ODD_QB.t5 VSS 0.28473f
C1250 ODD_QB.t0 VSS 0.28473f
C1251 ODD_QB.n3 VSS 0.80285f
C1252 ODD_QB.t4 VSS 1.1154f
C1253 ODD_QB.n4 VSS 0.41162f
C1254 ODD_QB.n5 VSS 4.3519f
C1255 ODD_Q.t6 VSS 1.33923f
C1256 ODD_Q.t1 VSS 0.326f
C1257 ODD_Q.t4 VSS 0.326f
C1258 ODD_Q.n0 VSS 0.97244f
C1259 ODD_Q.n1 VSS 0.47961f
C1260 ODD_Q.t2 VSS 1.33402f
C1261 ODD_Q.n2 VSS 1.51482f
C1262 ODD_Q.t0 VSS 0.326f
C1263 ODD_Q.t5 VSS 0.326f
C1264 ODD_Q.n3 VSS 0.97044f
C1265 ODD_Q.t3 VSS 1.32972f
C1266 ODD_Q.n4 VSS 0.48981f
C1267 ODD_Q.n5 VSS 2.90226f
C1268 EVEN_DB.n0 VSS 0.05822f
C1269 EVEN_DB.n1 VSS 0.20111f
C1270 EVEN_DB.n2 VSS 0.09941f
C1271 EVEN_DB.n3 VSS 0.10655f
C1272 EVEN_DB.n4 VSS 0.10655f
C1273 EVEN_DB.n5 VSS 0.20111f
C1274 EVEN_DB.n6 VSS 0.09941f
C1275 EVEN_DB.n7 VSS 0.10655f
C1276 EVEN_DB.n8 VSS 0.10655f
C1277 EVEN_DB.n9 VSS 0.10655f
C1278 EVEN_DB.n10 VSS 0.10655f
C1279 EVEN_DB.n11 VSS 0.05822f
C1280 EVEN_DB.n12 VSS 0.37995f
C1281 EVEN_DB.n13 VSS 0.09799f
C1282 EVEN_DB.n14 VSS 0.10655f
C1283 EVEN_DB.n15 VSS 0.10655f
C1284 EVEN_DB.n16 VSS 0.09799f
C1285 EVEN_DB.n17 VSS 0.29345f
C1286 EVEN_DB.n18 VSS 2.62373f
C1287 EVEN_D.n0 VSS 0.04878f
C1288 EVEN_D.n1 VSS 0.16852f
C1289 EVEN_D.n2 VSS 0.0833f
C1290 EVEN_D.n3 VSS 0.08928f
C1291 EVEN_D.n4 VSS 0.08928f
C1292 EVEN_D.n5 VSS 0.16852f
C1293 EVEN_D.n6 VSS 0.0833f
C1294 EVEN_D.n7 VSS 0.08928f
C1295 EVEN_D.n8 VSS 0.08928f
C1296 EVEN_D.n9 VSS 0.08928f
C1297 EVEN_D.n10 VSS 0.08928f
C1298 EVEN_D.n11 VSS 0.04878f
C1299 EVEN_D.n12 VSS 0.31837f
C1300 EVEN_D.n13 VSS 0.08211f
C1301 EVEN_D.n14 VSS 0.08928f
C1302 EVEN_D.n15 VSS 0.08928f
C1303 EVEN_D.n16 VSS 0.08211f
C1304 EVEN_D.n17 VSS 0.2459f
C1305 EVEN_D.n18 VSS 2.5333f
C1306 ODD_D.n0 VSS 0.04836f
C1307 ODD_D.n1 VSS 0.16707f
C1308 ODD_D.n2 VSS 0.08258f
C1309 ODD_D.n3 VSS 0.08852f
C1310 ODD_D.n4 VSS 0.08852f
C1311 ODD_D.n5 VSS 0.16707f
C1312 ODD_D.n6 VSS 0.08258f
C1313 ODD_D.n7 VSS 0.08852f
C1314 ODD_D.n8 VSS 0.08852f
C1315 ODD_D.n9 VSS 0.08852f
C1316 ODD_D.n10 VSS 0.08852f
C1317 ODD_D.n11 VSS 0.04836f
C1318 ODD_D.n12 VSS 0.31564f
C1319 ODD_D.n13 VSS 0.08141f
C1320 ODD_D.n14 VSS 0.08852f
C1321 ODD_D.n15 VSS 0.08852f
C1322 ODD_D.n16 VSS 0.08141f
C1323 ODD_D.n17 VSS 0.24379f
C1324 ODD_D.n18 VSS 2.38316f
C1325 ODD_DB.n0 VSS 0.05728f
C1326 ODD_DB.n1 VSS 0.19787f
C1327 ODD_DB.n2 VSS 0.0978f
C1328 ODD_DB.n3 VSS 0.10483f
C1329 ODD_DB.n4 VSS 0.10483f
C1330 ODD_DB.n5 VSS 0.19787f
C1331 ODD_DB.n6 VSS 0.0978f
C1332 ODD_DB.n7 VSS 0.10483f
C1333 ODD_DB.n8 VSS 0.10483f
C1334 ODD_DB.n9 VSS 0.10483f
C1335 ODD_DB.n10 VSS 0.10483f
C1336 ODD_DB.n11 VSS 0.05728f
C1337 ODD_DB.n12 VSS 0.37382f
C1338 ODD_DB.n13 VSS 0.09641f
C1339 ODD_DB.n14 VSS 0.10483f
C1340 ODD_DB.n15 VSS 0.10483f
C1341 ODD_DB.n16 VSS 0.09641f
C1342 ODD_DB.n17 VSS 0.28872f
C1343 ODD_DB.n18 VSS 2.52299f
C1344 EVEN_CAPTURE_CLK.n0 VSS 0.03978f
C1345 EVEN_CAPTURE_CLK.n1 VSS 0.02725f
C1346 EVEN_CAPTURE_CLK.n2 VSS 0.02725f
C1347 EVEN_CAPTURE_CLK.n3 VSS 0.02725f
C1348 EVEN_CAPTURE_CLK.n4 VSS 0.07931f
C1349 EVEN_CAPTURE_CLK.n5 VSS 0.0392f
C1350 EVEN_CAPTURE_CLK.n6 VSS 0.04202f
C1351 EVEN_CAPTURE_CLK.n7 VSS 0.04202f
C1352 EVEN_CAPTURE_CLK.n8 VSS 0.04202f
C1353 EVEN_CAPTURE_CLK.n9 VSS 0.04202f
C1354 EVEN_CAPTURE_CLK.n10 VSS 0.04202f
C1355 EVEN_CAPTURE_CLK.n11 VSS 0.04202f
C1356 EVEN_CAPTURE_CLK.n12 VSS 0.02296f
C1357 EVEN_CAPTURE_CLK.n13 VSS 0.18619f
C1358 EVEN_CAPTURE_CLK.n14 VSS 0.03864f
C1359 EVEN_CAPTURE_CLK.n15 VSS 0.02725f
C1360 EVEN_CAPTURE_CLK.n16 VSS 0.04202f
C1361 EVEN_CAPTURE_CLK.n17 VSS 0.04202f
C1362 EVEN_CAPTURE_CLK.n18 VSS 0.0392f
C1363 EVEN_CAPTURE_CLK.n19 VSS 0.07931f
C1364 EVEN_CAPTURE_CLK.n20 VSS 0.02725f
C1365 EVEN_CAPTURE_CLK.n21 VSS 0.04202f
C1366 EVEN_CAPTURE_CLK.n22 VSS 0.04202f
C1367 EVEN_CAPTURE_CLK.n23 VSS 0.04202f
C1368 EVEN_CAPTURE_CLK.n24 VSS 0.04202f
C1369 EVEN_CAPTURE_CLK.n25 VSS 0.02296f
C1370 EVEN_CAPTURE_CLK.n26 VSS 0.07655f
C1371 EVEN_CAPTURE_CLK.n27 VSS 1.12394f
C1372 ODD_CAPTURE_CLK.n0 VSS 0.04219f
C1373 ODD_CAPTURE_CLK.n1 VSS 0.0289f
C1374 ODD_CAPTURE_CLK.n2 VSS 0.0289f
C1375 ODD_CAPTURE_CLK.n3 VSS 0.0289f
C1376 ODD_CAPTURE_CLK.n4 VSS 0.08413f
C1377 ODD_CAPTURE_CLK.n5 VSS 0.04158f
C1378 ODD_CAPTURE_CLK.n6 VSS 0.04457f
C1379 ODD_CAPTURE_CLK.n7 VSS 0.04457f
C1380 ODD_CAPTURE_CLK.n8 VSS 0.04457f
C1381 ODD_CAPTURE_CLK.n9 VSS 0.04457f
C1382 ODD_CAPTURE_CLK.n10 VSS 0.04457f
C1383 ODD_CAPTURE_CLK.n11 VSS 0.04457f
C1384 ODD_CAPTURE_CLK.n12 VSS 0.02435f
C1385 ODD_CAPTURE_CLK.n13 VSS 0.25998f
C1386 ODD_CAPTURE_CLK.n14 VSS 0.04099f
C1387 ODD_CAPTURE_CLK.n15 VSS 0.0289f
C1388 ODD_CAPTURE_CLK.n16 VSS 0.04457f
C1389 ODD_CAPTURE_CLK.n17 VSS 0.04457f
C1390 ODD_CAPTURE_CLK.n18 VSS 0.04158f
C1391 ODD_CAPTURE_CLK.n19 VSS 0.08413f
C1392 ODD_CAPTURE_CLK.n20 VSS 0.0289f
C1393 ODD_CAPTURE_CLK.n21 VSS 0.04457f
C1394 ODD_CAPTURE_CLK.n22 VSS 0.04457f
C1395 ODD_CAPTURE_CLK.n23 VSS 0.04457f
C1396 ODD_CAPTURE_CLK.n24 VSS 0.04457f
C1397 ODD_CAPTURE_CLK.n25 VSS 0.02435f
C1398 ODD_CAPTURE_CLK.n26 VSS 0.13692f
C1399 ODD_CAPTURE_CLK.n27 VSS 1.30122f
.ends
