* PEX produced using /foss/tools/sak/sak-pex.sh with m=3 and s=1 (extresist threshold=0 mOhm, minres=1 mOhm, mindelay=0 ps)
* NGSPICE file created from serdes_rx_pex.ext - technology: gf180mcuD

.subckt serdes_rx_pex RXP RXN VTHP VTHN VBIAS BW_EN_N VDD VSS OUTP OUTN
X0 VSS.t36 VBIAS.t4 a_2148_n500.t4 VSS.t35 nfet_03v3 ad=2.6p pd=10.52u as=4.4p ps=20.88u w=10u l=0.28u
X1 a_n5052_2600.t2 VTHN.t1 a_n3600_5641.t1 VSS.t9 nfet_03v3 ad=0.52p pd=2.52u as=0.88p ps=4.88u w=2u l=0.28u
X2 VSS.t24 VBIAS.t13 a_n5052_2600.t4 VSS.t23 nfet_03v3 ad=0.52p pd=2.52u as=0.88p ps=4.88u w=2u l=0.28u
X3 a_2148_n500.t2 a_n6572_3500.t7 OUTP.t1 VSS.t5 nfet_03v3 ad=1.3p pd=5.52u as=2.2p ps=10.88u w=5u l=0.28u
X4 a_n5052_2600.t5 VBIAS.t12 VSS.t26 VSS.t25 nfet_03v3 ad=0.52p pd=2.52u as=0.52p ps=2.52u w=2u l=0.28u
X5 OUTP.t2 BW_EN_N.t1 a_484_3500.t1 VDD.t5 pfet_03v3 ad=2.2p pd=10.88u as=2.2p ps=10.88u w=5u l=0.28u
X6 a_n5052_n1000.t5 VBIAS.t8 VSS.t18 VSS.t17 nfet_03v3 ad=2.6p pd=10.52u as=2.6p ps=10.52u w=10u l=0.28u
X7 a_n1900_5958.t0 BW_EN_N.t2 a_n3600_5641.t0 VDD.t4 pfet_03v3 ad=2.2p pd=10.88u as=2.2p ps=10.88u w=5u l=0.28u
X8 OUTN.t1 a_n3600_5641.t6 a_2148_n500.t3 VSS.t6 nfet_03v3 ad=2.2p pd=10.88u as=1.3p ps=5.52u w=5u l=0.28u
X9 a_n6572_3500.t2 BW_EN_N.t3 a_n6716_3500.t0 VDD.t3 pfet_03v3 ad=2.2p pd=10.88u as=2.2p ps=10.88u w=5u l=0.28u
X10 VSS.t34 VBIAS.t2 a_2148_n500.t6 VSS.t33 nfet_03v3 ad=2.6p pd=10.52u as=2.6p ps=10.52u w=10u l=0.28u
X11 a_n3600_5641.t2 VTHN.t0 a_n5052_2600.t3 VSS.t10 nfet_03v3 ad=0.88p pd=4.88u as=0.52p ps=2.52u w=2u l=0.28u
X12 a_n5052_2600.t7 VBIAS.t10 VSS.t22 VSS.t21 nfet_03v3 ad=0.88p pd=4.88u as=0.52p ps=2.52u w=2u l=0.28u
X13 a_n6572_3500.t5 RXP.t0 a_n5052_n1000.t2 VSS.t3 nfet_03v3 ad=4.4p pd=20.88u as=2.6p ps=10.52u w=10u l=0.28u
X14 VDD.t2 OUTN.t2 VSS.t8 ppolyf_u r_width=2u r_length=3.43u
X15 VSS.t42 VBIAS.t0 a_2148_n500.t8 VSS.t41 nfet_03v3 ad=4.4p pd=20.88u as=2.6p ps=10.52u w=10u l=0.28u
X16 VSS.t28 VBIAS.t11 a_n5052_2600.t6 VSS.t27 nfet_03v3 ad=0.52p pd=2.52u as=0.52p ps=2.52u w=2u l=0.28u
X17 a_n5052_n1000.t3 RXP.t1 a_n6572_3500.t4 VSS.t2 nfet_03v3 ad=2.6p pd=10.52u as=4.4p ps=20.88u w=10u l=0.28u
X18 a_2148_n500.t0 a_n3600_5641.t7 OUTN.t0 VSS.t0 nfet_03v3 ad=1.3p pd=5.52u as=2.2p ps=10.88u w=5u l=0.28u
X19 a_n5052_n1000.t0 RXN.t1 a_n3600_5641.t3 VSS.t9 nfet_03v3 ad=2.6p pd=10.52u as=4.4p ps=20.88u w=10u l=0.28u
X20 VSS.t16 VBIAS.t5 a_n5052_n1000.t8 VSS.t15 nfet_03v3 ad=4.4p pd=20.88u as=2.6p ps=10.52u w=10u l=0.28u
X21 VDD.t8 a_n6572_3500.t3 VSS.t12 ppolyf_u r_width=2u r_length=4.57u
X22 VDD.t0 a_5300_5958.t0 VSS.t1 ppolyf_u r_width=1u r_length=1.4u
X23 VSS.t30 VBIAS.t7 a_n5052_n1000.t6 VSS.t29 nfet_03v3 ad=2.6p pd=10.52u as=2.6p ps=10.52u w=10u l=0.28u
X24 OUTP.t0 a_n6572_3500.t6 a_2148_n500.t1 VSS.t4 nfet_03v3 ad=2.2p pd=10.88u as=1.3p ps=5.52u w=5u l=0.28u
X25 VDD.t7 a_n1900_5958.t1 VSS.t11 ppolyf_u r_width=1u r_length=1.4u
X26 a_n6572_3500.t1 VTHP.t0 a_n5052_2600.t1 VSS.t3 nfet_03v3 ad=0.88p pd=4.88u as=0.52p ps=2.52u w=2u l=0.28u
X27 a_2148_n500.t5 VBIAS.t3 VSS.t38 VSS.t37 nfet_03v3 ad=2.6p pd=10.52u as=2.6p ps=10.52u w=10u l=0.28u
X28 VDD.t9 a_n6716_3500.t1 VSS.t13 ppolyf_u r_width=1u r_length=1.4u
X29 a_n5052_2600.t0 VTHP.t1 a_n6572_3500.t0 VSS.t2 nfet_03v3 ad=0.52p pd=2.52u as=0.88p ps=4.88u w=2u l=0.28u
X30 VDD.t11 a_n3600_5641.t5 VSS.t43 ppolyf_u r_width=2u r_length=4.57u
X31 a_5300_5958.t1 BW_EN_N.t0 OUTN.t3 VDD.t6 pfet_03v3 ad=2.2p pd=10.88u as=2.2p ps=10.88u w=5u l=0.28u
X32 a_n3600_5641.t4 RXN.t0 a_n5052_n1000.t1 VSS.t10 nfet_03v3 ad=4.4p pd=20.88u as=2.6p ps=10.52u w=10u l=0.28u
X33 VDD.t10 OUTP.t3 VSS.t14 ppolyf_u r_width=2u r_length=3.43u
X34 a_n5052_n1000.t7 VBIAS.t6 VSS.t32 VSS.t31 nfet_03v3 ad=2.6p pd=10.52u as=2.6p ps=10.52u w=10u l=0.28u
X35 a_2148_n500.t7 VBIAS.t1 VSS.t40 VSS.t39 nfet_03v3 ad=2.6p pd=10.52u as=2.6p ps=10.52u w=10u l=0.28u
X36 VSS.t20 VBIAS.t9 a_n5052_n1000.t4 VSS.t19 nfet_03v3 ad=2.6p pd=10.52u as=4.4p ps=20.88u w=10u l=0.28u
X37 VDD.t1 a_484_3500.t0 VSS.t7 ppolyf_u r_width=1u r_length=1.4u
R0 RXN.n0 RXN.t1 139.689
R1 RXN.n0 RXN.t0 139.689
R2 RXN RXN.n0 22.4916
R3 RXP.n0 RXP.t1 139.689
R4 RXP.n0 RXP.t0 139.689
R5 RXP RXP.n0 22.4916
R6 VBIAS.n4 VBIAS.t4 139.702
R7 VBIAS.n0 VBIAS.t0 139.702
R8 VBIAS.n15 VBIAS.t9 139.702
R9 VBIAS.n11 VBIAS.t5 139.702
R10 VBIAS.n1 VBIAS.t1 135.246
R11 VBIAS.n2 VBIAS.t2 135.246
R12 VBIAS.n3 VBIAS.t3 135.246
R13 VBIAS.n12 VBIAS.t6 135.246
R14 VBIAS.n13 VBIAS.t7 135.246
R15 VBIAS.n14 VBIAS.t8 135.246
R16 VBIAS.n6 VBIAS.t10 35.4171
R17 VBIAS.n9 VBIAS.t13 35.4171
R18 VBIAS.n7 VBIAS.t11 30.9603
R19 VBIAS.n8 VBIAS.t12 30.9603
R20 VBIAS.n17 VBIAS.n10 21.4384
R21 VBIAS VBIAS.n5 19.0005
R22 VBIAS.n5 VBIAS.n2 18.4942
R23 VBIAS.n16 VBIAS.n13 18.4942
R24 VBIAS.n17 VBIAS.n16 18.0005
R25 VBIAS.n8 VBIAS.n7 11.6805
R26 VBIAS.n2 VBIAS.n1 11.6805
R27 VBIAS.n3 VBIAS.n2 11.6805
R28 VBIAS.n13 VBIAS.n12 11.6805
R29 VBIAS.n14 VBIAS.n13 11.6805
R30 VBIAS.n5 VBIAS.n0 7.16487
R31 VBIAS.n5 VBIAS.n4 7.16487
R32 VBIAS.n16 VBIAS.n11 7.16487
R33 VBIAS.n16 VBIAS.n15 7.16487
R34 VBIAS.n10 VBIAS.n6 7.09873
R35 VBIAS.n10 VBIAS.n9 7.09873
R36 VBIAS.n7 VBIAS.n6 4.42851
R37 VBIAS.n9 VBIAS.n8 4.42851
R38 VBIAS.n1 VBIAS.n0 4.42851
R39 VBIAS.n4 VBIAS.n3 4.42851
R40 VBIAS.n12 VBIAS.n11 4.42851
R41 VBIAS.n15 VBIAS.n14 4.42851
R42 VBIAS VBIAS.n17 0.895237
R43 VTHN.n0 VTHN.t0 35.4171
R44 VTHN.n0 VTHN.t1 35.3883
R45 VTHN VTHN.n0 26.1942
R46 VTHP.n0 VTHP.t1 35.4171
R47 VTHP.n0 VTHP.t0 35.3883
R48 VTHP VTHP.n0 26.1942
R49 BW_EN_N.n1 BW_EN_N.t3 104.718
R50 BW_EN_N.n0 BW_EN_N.t0 104.718
R51 BW_EN_N.n1 BW_EN_N.t2 102.35
R52 BW_EN_N.n0 BW_EN_N.t1 102.35
R53 BW_EN_N BW_EN_N.n0 1.06629
R54 BW_EN_N BW_EN_N.n1 0.829447
R55 OUTN OUTN.t2 12.6529
R56 OUTN.n1 OUTN.t3 10.6142
R57 OUTN.n0 OUTN.t0 6.0676
R58 OUTN.n0 OUTN.t1 6.06436
R59 OUTN.n1 OUTN.n0 3.78254
R60 OUTN OUTN.n1 0.409591
R61 OUTP OUTP.t3 12.6529
R62 OUTP.n1 OUTP.t2 10.6142
R63 OUTP.n0 OUTP.t0 6.0676
R64 OUTP.n0 OUTP.t1 6.06436
R65 OUTP.n1 OUTP.n0 3.78254
R66 OUTP OUTP.n1 0.409591
R67 VDD.t4 VDD.t3 2823.53
R68 VDD.t6 VDD.t5 2823.53
R69 VDD.t5 VDD.t4 1411.76
R70 VDD.n0 VDD.t6 407.851
R71 VDD.n4 VDD.t9 25.1121
R72 VDD.n0 VDD.t0 24.7565
R73 VDD.n3 VDD.t1 24.7565
R74 VDD.n6 VDD.t7 24.7565
R75 VDD.n1 VDD.t2 21.4505
R76 VDD.n2 VDD.t10 21.4505
R77 VDD.n5 VDD.t11 21.3935
R78 VDD.n4 VDD.t8 21.3935
R79 VDD.n5 VDD.n4 0.356056
R80 VDD.n6 VDD.n5 0.356056
R81 VDD VDD.n6 0.356056
R82 VDD.n3 VDD.n2 0.356056
R83 VDD.n2 VDD.n1 0.356056
R84 VDD.n1 VDD.n0 0.356056
R85 VDD VDD.n3 0.178278
R86 VSS.n31 VSS.n25 14895.8
R87 VSS.n144 VSS.n5 8937.5
R88 VSS.n87 VSS.n25 8125
R89 VSS.n118 VSS.n5 4875
R90 VSS.n101 VSS.n100 1392.86
R91 VSS.n96 VSS.n21 981.453
R92 VSS.n90 VSS.n21 981.453
R93 VSS.n111 VSS.n108 981.367
R94 VSS.n108 VSS.n107 981.367
R95 VSS.n109 VSS.n13 633.46
R96 VSS.n100 VSS.n17 633.46
R97 VSS.n99 VSS.n98 633.46
R98 VSS.n88 VSS.n87 557.144
R99 VSS.n98 VSS.n97 517.168
R100 VSS.n110 VSS.n109 517.082
R101 VSS.n145 VSS.n4 481.481
R102 VSS.n52 VSS.n41 481.481
R103 VSS.n53 VSS.n52 481.481
R104 VSS.n54 VSS.n53 481.481
R105 VSS.n118 VSS.n117 464.286
R106 VSS.t10 VSS.n41 449.384
R107 VSS.n61 VSS.t6 449.384
R108 VSS.n62 VSS.n61 320.988
R109 VSS.t2 VSS.n4 288.889
R110 VSS.n54 VSS.t5 288.889
R111 VSS.n110 VSS.t12 205.746
R112 VSS.n108 VSS.t43 205.746
R113 VSS.n97 VSS.t14 205.703
R114 VSS.t8 VSS.n21 205.703
R115 VSS.n62 VSS.n31 192.594
R116 VSS.n117 VSS.n13 169.173
R117 VSS.n107 VSS.n17 169.173
R118 VSS.n101 VSS.n99 169.173
R119 VSS.n90 VSS.n89 169.173
R120 VSS.n89 VSS.n88 169.173
R121 VSS.n145 VSS.n144 160.494
R122 VSS.t9 VSS.t15 160.494
R123 VSS.t41 VSS.t0 160.494
R124 VSS.n13 VSS.t13 147.558
R125 VSS.n17 VSS.t11 147.558
R126 VSS.n99 VSS.t7 147.558
R127 VSS.n89 VSS.t1 147.558
R128 VSS.n119 VSS.n118 139.716
R129 VSS.n45 VSS.t3 128.395
R130 VSS.t4 VSS.n40 128.395
R131 VSS.t3 VSS.t2 64.198
R132 VSS.t5 VSS.t4 64.198
R133 VSS.t35 VSS.t37 64.198
R134 VSS.t37 VSS.t33 64.198
R135 VSS.t33 VSS.t39 64.198
R136 VSS.t39 VSS.t41 64.198
R137 VSS.n116 VSS.n12 59.5005
R138 VSS.n85 VSS.n24 59.5005
R139 VSS.n97 VSS.n96 52.882
R140 VSS.n111 VSS.n110 52.7956
R141 VSS.n146 VSS.n2 52.5005
R142 VSS.n44 VSS.n2 52.5005
R143 VSS.n47 VSS.n44 52.5005
R144 VSS.n47 VSS.n42 52.5005
R145 VSS.n51 VSS.n42 52.5005
R146 VSS.n51 VSS.n39 52.5005
R147 VSS.n55 VSS.n39 52.5005
R148 VSS.n55 VSS.n36 52.5005
R149 VSS.n59 VSS.n36 52.5005
R150 VSS.n59 VSS.n35 52.5005
R151 VSS.n130 VSS.n129 52.5005
R152 VSS.n134 VSS.n133 52.5005
R153 VSS.n142 VSS.n10 52.5005
R154 VSS.n142 VSS.n9 52.5005
R155 VSS.n120 VSS.n9 52.5005
R156 VSS.n116 VSS.n14 52.5005
R157 VSS.n112 VSS.n14 52.5005
R158 VSS.n112 VSS.n16 52.5005
R159 VSS.n106 VSS.n16 52.5005
R160 VSS.n106 VSS.n18 52.5005
R161 VSS.n102 VSS.n18 52.5005
R162 VSS.n102 VSS.n20 52.5005
R163 VSS.n95 VSS.n20 52.5005
R164 VSS.n95 VSS.n22 52.5005
R165 VSS.n91 VSS.n22 52.5005
R166 VSS.n73 VSS.n72 52.5005
R167 VSS.n77 VSS.n32 52.5005
R168 VSS.n77 VSS.n28 52.5005
R169 VSS.n81 VSS.n80 52.5005
R170 VSS.n81 VSS.n26 52.5005
R171 VSS.n146 VSS.n3 50.7505
R172 VSS.n64 VSS.n63 50.7505
R173 VSS.n144 VSS.n143 48.1486
R174 VSS.n87 VSS.n86 46.8595
R175 VSS.n63 VSS.n35 35.0005
R176 VSS.n91 VSS.n24 35.0005
R177 VSS.t19 VSS.n45 32.0993
R178 VSS.t23 VSS.t19 32.0993
R179 VSS.t17 VSS.t23 32.0993
R180 VSS.t25 VSS.t17 32.0993
R181 VSS.t29 VSS.t25 32.0993
R182 VSS.t27 VSS.t29 32.0993
R183 VSS.t31 VSS.t27 32.0993
R184 VSS.t21 VSS.t31 32.0993
R185 VSS.t15 VSS.t21 32.0993
R186 VSS.n46 VSS.t9 32.0993
R187 VSS.n46 VSS.t10 32.0993
R188 VSS.n40 VSS.t35 32.0993
R189 VSS.n60 VSS.t0 32.0993
R190 VSS.t6 VSS.n60 32.0993
R191 VSS.n149 VSS.n148 18.7389
R192 VSS.n78 VSS.n31 16.0499
R193 VSS.n124 VSS.t16 6.57557
R194 VSS.n138 VSS.n136 6.49615
R195 VSS.n69 VSS.t42 6.45713
R196 VSS.n68 VSS.n67 6.41078
R197 VSS.n138 VSS.n137 6.31615
R198 VSS.n68 VSS.n66 6.29483
R199 VSS.n124 VSS.n123 6.29483
R200 VSS.n126 VSS.n125 6.29333
R201 VSS.n139 VSS.n138 6.278
R202 VSS.n127 VSS.n126 5.6555
R203 VSS.n70 VSS.n69 5.5955
R204 VSS.n12 VSS.n11 5.2005
R205 VSS.n121 VSS.n120 5.2005
R206 VSS.n9 VSS.n5 5.2005
R207 VSS.n122 VSS.n9 5.2005
R208 VSS.n143 VSS.n142 5.2005
R209 VSS.n142 VSS.n141 5.2005
R210 VSS.n140 VSS.n10 5.2005
R211 VSS.n135 VSS.n134 5.2005
R212 VSS.n133 VSS.n132 5.2005
R213 VSS.n131 VSS.n130 5.2005
R214 VSS.n129 VSS.n128 5.2005
R215 VSS.n3 VSS.n0 5.2005
R216 VSS.n117 VSS.n116 5.2005
R217 VSS.n116 VSS.n115 5.2005
R218 VSS.n109 VSS.n14 5.2005
R219 VSS.n114 VSS.n14 5.2005
R220 VSS.n112 VSS.n111 5.2005
R221 VSS.n113 VSS.n112 5.2005
R222 VSS.t43 VSS.n16 5.2005
R223 VSS.n16 VSS.n15 5.2005
R224 VSS.n107 VSS.n106 5.2005
R225 VSS.n106 VSS.n105 5.2005
R226 VSS.n100 VSS.n18 5.2005
R227 VSS.n104 VSS.n18 5.2005
R228 VSS.n102 VSS.n101 5.2005
R229 VSS.n103 VSS.n102 5.2005
R230 VSS.n98 VSS.n20 5.2005
R231 VSS.n20 VSS.n19 5.2005
R232 VSS.n96 VSS.n95 5.2005
R233 VSS.n95 VSS.n94 5.2005
R234 VSS.n22 VSS.t8 5.2005
R235 VSS.n93 VSS.n22 5.2005
R236 VSS.n91 VSS.n90 5.2005
R237 VSS.n92 VSS.n91 5.2005
R238 VSS.n88 VSS.n24 5.2005
R239 VSS.n24 VSS.n23 5.2005
R240 VSS.n65 VSS.n64 5.2005
R241 VSS.n72 VSS.n71 5.2005
R242 VSS.n74 VSS.n73 5.2005
R243 VSS.n75 VSS.n32 5.2005
R244 VSS.n78 VSS.n77 5.2005
R245 VSS.n77 VSS.n76 5.2005
R246 VSS.n33 VSS.n28 5.2005
R247 VSS.n80 VSS.n27 5.2005
R248 VSS.n81 VSS.n25 5.2005
R249 VSS.n82 VSS.n81 5.2005
R250 VSS.n83 VSS.n26 5.2005
R251 VSS.n85 VSS.n84 5.2005
R252 VSS.n63 VSS.n62 5.2005
R253 VSS.n63 VSS.n34 5.2005
R254 VSS.n61 VSS.n35 5.2005
R255 VSS.n37 VSS.n35 5.2005
R256 VSS.n60 VSS.n59 5.2005
R257 VSS.n59 VSS.n58 5.2005
R258 VSS.n40 VSS.n36 5.2005
R259 VSS.n57 VSS.n36 5.2005
R260 VSS.n55 VSS.n54 5.2005
R261 VSS.n56 VSS.n55 5.2005
R262 VSS.n53 VSS.n39 5.2005
R263 VSS.n39 VSS.n38 5.2005
R264 VSS.n52 VSS.n51 5.2005
R265 VSS.n51 VSS.n50 5.2005
R266 VSS.n42 VSS.n41 5.2005
R267 VSS.n49 VSS.n42 5.2005
R268 VSS.n47 VSS.n46 5.2005
R269 VSS.n48 VSS.n47 5.2005
R270 VSS.n45 VSS.n44 5.2005
R271 VSS.n44 VSS.n43 5.2005
R272 VSS.n4 VSS.n2 5.2005
R273 VSS.n2 VSS.n1 5.2005
R274 VSS.n146 VSS.n145 5.2005
R275 VSS.n147 VSS.n146 5.2005
R276 VSS.n119 VSS.n12 4.34122
R277 VSS.n10 VSS.n8 4.34122
R278 VSS.n133 VSS.n7 4.34122
R279 VSS.n129 VSS.n6 4.34122
R280 VSS.n64 VSS.n30 4.34122
R281 VSS.n73 VSS.n29 4.34122
R282 VSS.n79 VSS.n28 4.34122
R283 VSS.n86 VSS.n26 4.34122
R284 VSS.n6 VSS.n3 4.34122
R285 VSS.n130 VSS.n7 4.34122
R286 VSS.n134 VSS.n8 4.34122
R287 VSS.n120 VSS.n119 4.34122
R288 VSS.n72 VSS.n30 4.34122
R289 VSS.n32 VSS.n29 4.34122
R290 VSS.n80 VSS.n79 4.34122
R291 VSS.n86 VSS.n85 4.34122
R292 VSS.n149 VSS 3.1324
R293 VSS.n136 VSS.t28 0.8195
R294 VSS.n136 VSS.t22 0.8195
R295 VSS.n137 VSS.t24 0.8195
R296 VSS.n137 VSS.t26 0.8195
R297 VSS.n115 VSS.n11 0.7655
R298 VSS.n84 VSS.n23 0.7655
R299 VSS.n131 VSS.n128 0.6755
R300 VSS.n132 VSS.n131 0.6755
R301 VSS.n135 VSS.n132 0.6755
R302 VSS.n141 VSS.n140 0.6755
R303 VSS.n141 VSS.n122 0.6755
R304 VSS.n122 VSS.n121 0.6755
R305 VSS.n121 VSS.n11 0.6755
R306 VSS.n115 VSS.n114 0.6755
R307 VSS.n114 VSS.n113 0.6755
R308 VSS.n113 VSS.n15 0.6755
R309 VSS.n105 VSS.n15 0.6755
R310 VSS.n105 VSS.n104 0.6755
R311 VSS.n104 VSS.n103 0.6755
R312 VSS.n103 VSS.n19 0.6755
R313 VSS.n94 VSS.n19 0.6755
R314 VSS.n94 VSS.n93 0.6755
R315 VSS.n93 VSS.n92 0.6755
R316 VSS.n74 VSS.n71 0.6755
R317 VSS.n75 VSS.n74 0.6755
R318 VSS.n76 VSS.n75 0.6755
R319 VSS.n76 VSS.n33 0.6755
R320 VSS.n33 VSS.n27 0.6755
R321 VSS.n82 VSS.n27 0.6755
R322 VSS.n83 VSS.n82 0.6755
R323 VSS.n84 VSS.n83 0.6755
R324 VSS.n147 VSS.n1 0.6755
R325 VSS.n43 VSS.n1 0.6755
R326 VSS.n48 VSS.n43 0.6755
R327 VSS.n49 VSS.n48 0.6755
R328 VSS.n50 VSS.n49 0.6755
R329 VSS.n50 VSS.n38 0.6755
R330 VSS.n56 VSS.n38 0.6755
R331 VSS.n57 VSS.n56 0.6755
R332 VSS.n58 VSS.n57 0.6755
R333 VSS.n58 VSS.n37 0.6755
R334 VSS.n65 VSS.n34 0.653
R335 VSS VSS.n150 0.554184
R336 VSS.n150 VSS 0.468056
R337 VSS.n128 VSS.n127 0.4505
R338 VSS.n92 VSS.n23 0.4505
R339 VSS.n71 VSS.n70 0.4505
R340 VSS.n37 VSS.n34 0.4505
R341 VSS.n143 VSS.n8 0.430889
R342 VSS.n143 VSS.n7 0.430889
R343 VSS.n143 VSS.n6 0.430889
R344 VSS.n78 VSS.n30 0.430889
R345 VSS.n78 VSS.n29 0.430889
R346 VSS.n79 VSS.n78 0.430889
R347 VSS.n148 VSS.n147 0.37175
R348 VSS.n139 VSS.n135 0.3605
R349 VSS.n140 VSS.n139 0.3155
R350 VSS.n148 VSS.n0 0.28175
R351 VSS.n127 VSS.n0 0.2255
R352 VSS.n70 VSS.n65 0.2255
R353 VSS.n66 VSS.t34 0.1643
R354 VSS.n66 VSS.t40 0.1643
R355 VSS.n67 VSS.t36 0.1643
R356 VSS.n67 VSS.t38 0.1643
R357 VSS.n123 VSS.t30 0.1643
R358 VSS.n123 VSS.t32 0.1643
R359 VSS.n125 VSS.t20 0.1643
R360 VSS.n125 VSS.t18 0.1643
R361 VSS.n69 VSS.n68 0.118945
R362 VSS.n126 VSS.n124 0.117954
R363 VSS.n150 VSS.n149 0.0105041
R364 a_2148_n500.n5 a_2148_n500.n3 10.5451
R365 a_2148_n500.n5 a_2148_n500.n4 10.5451
R366 a_2148_n500.n2 a_2148_n500.t4 6.45713
R367 a_2148_n500.n8 a_2148_n500.n7 6.38754
R368 a_2148_n500.n1 a_2148_n500.n0 6.29333
R369 a_2148_n500.n6 a_2148_n500.n2 4.68405
R370 a_2148_n500.n7 a_2148_n500.n6 2.22659
R371 a_2148_n500.n6 a_2148_n500.n5 0.8055
R372 a_2148_n500.n3 a_2148_n500.t0 0.3281
R373 a_2148_n500.n3 a_2148_n500.t3 0.3281
R374 a_2148_n500.n4 a_2148_n500.t2 0.3281
R375 a_2148_n500.n4 a_2148_n500.t1 0.3281
R376 a_2148_n500.n2 a_2148_n500.n1 0.189974
R377 a_2148_n500.t7 a_2148_n500.n8 0.1643
R378 a_2148_n500.n8 a_2148_n500.t8 0.1643
R379 a_2148_n500.n0 a_2148_n500.t5 0.1643
R380 a_2148_n500.n0 a_2148_n500.t6 0.1643
R381 a_2148_n500.n7 a_2148_n500.n1 0.0928953
R382 a_n5052_n1000.n5 a_n5052_n1000.n3 11.1933
R383 a_n5052_n1000.n5 a_n5052_n1000.n4 11.1933
R384 a_n5052_n1000.n2 a_n5052_n1000.t4 6.45713
R385 a_n5052_n1000.n8 a_n5052_n1000.n7 6.38754
R386 a_n5052_n1000.n1 a_n5052_n1000.n0 6.29333
R387 a_n5052_n1000.n6 a_n5052_n1000.n2 4.68405
R388 a_n5052_n1000.n7 a_n5052_n1000.n6 2.22659
R389 a_n5052_n1000.n6 a_n5052_n1000.n5 0.5555
R390 a_n5052_n1000.n2 a_n5052_n1000.n1 0.189974
R391 a_n5052_n1000.t7 a_n5052_n1000.n8 0.1643
R392 a_n5052_n1000.n8 a_n5052_n1000.t8 0.1643
R393 a_n5052_n1000.n0 a_n5052_n1000.t5 0.1643
R394 a_n5052_n1000.n0 a_n5052_n1000.t6 0.1643
R395 a_n5052_n1000.n3 a_n5052_n1000.t0 0.1643
R396 a_n5052_n1000.n3 a_n5052_n1000.t1 0.1643
R397 a_n5052_n1000.n4 a_n5052_n1000.t3 0.1643
R398 a_n5052_n1000.n4 a_n5052_n1000.t2 0.1643
R399 a_n5052_n1000.n7 a_n5052_n1000.n1 0.0928953
R400 a_n5052_2600.n3 a_n5052_2600.t7 7.27134
R401 a_n5052_2600.n3 a_n5052_2600.t4 7.27134
R402 a_n5052_2600.n2 a_n5052_2600.n0 6.71615
R403 a_n5052_2600.n2 a_n5052_2600.n1 6.71615
R404 a_n5052_2600.n4 a_n5052_2600.n3 6.31615
R405 a_n5052_2600.n4 a_n5052_2600.t5 0.8195
R406 a_n5052_2600.t6 a_n5052_2600.n4 0.8195
R407 a_n5052_2600.n0 a_n5052_2600.t2 0.8195
R408 a_n5052_2600.n0 a_n5052_2600.t3 0.8195
R409 a_n5052_2600.n1 a_n5052_2600.t0 0.8195
R410 a_n5052_2600.n1 a_n5052_2600.t1 0.8195
R411 a_n5052_2600.n3 a_n5052_2600.n2 0.3955
R412 a_5300_5958.t1 a_5300_5958.t0 26.7478
R413 a_484_3500.t1 a_484_3500.t0 26.7478
R414 a_n1900_5958.t0 a_n1900_5958.t1 26.7478
R415 a_n3600_5641.n3 a_n3600_5641.t6 74.5091
R416 a_n3600_5641.n3 a_n3600_5641.t7 74.5091
R417 a_n3600_5641.n4 a_n3600_5641.n3 37.8057
R418 a_n3600_5641.n1 a_n3600_5641.t5 13.0154
R419 a_n3600_5641.n1 a_n3600_5641.t0 10.6142
R420 a_n3600_5641.n0 a_n3600_5641.t1 7.23009
R421 a_n3600_5641.n0 a_n3600_5641.t2 7.22685
R422 a_n3600_5641.n5 a_n3600_5641.t3 6.55206
R423 a_n3600_5641.t4 a_n3600_5641.n5 6.54882
R424 a_n3600_5641.n5 a_n3600_5641.n4 2.75982
R425 a_n3600_5641.n2 a_n3600_5641.n0 2.26891
R426 a_n3600_5641.n2 a_n3600_5641.n1 0.425955
R427 a_n3600_5641.n4 a_n3600_5641.n2 0.393227
R428 a_n6572_3500.n3 a_n6572_3500.t6 74.5091
R429 a_n6572_3500.n3 a_n6572_3500.t7 74.5091
R430 a_n6572_3500.n4 a_n6572_3500.n3 37.5518
R431 a_n6572_3500.n1 a_n6572_3500.t3 13.0154
R432 a_n6572_3500.n1 a_n6572_3500.t2 10.6142
R433 a_n6572_3500.n0 a_n6572_3500.t1 7.23009
R434 a_n6572_3500.n0 a_n6572_3500.t0 7.22685
R435 a_n6572_3500.t5 a_n6572_3500.n5 6.55206
R436 a_n6572_3500.n5 a_n6572_3500.t4 6.54882
R437 a_n6572_3500.n5 a_n6572_3500.n4 2.59618
R438 a_n6572_3500.n2 a_n6572_3500.n0 2.26891
R439 a_n6572_3500.n4 a_n6572_3500.n2 0.556864
R440 a_n6572_3500.n2 a_n6572_3500.n1 0.425955
R441 a_n6716_3500.t0 a_n6716_3500.t1 26.7478
C0 BW_EN_N VTHN 0.14867f
C1 BW_EN_N OUTP 0.35637f
C2 BW_EN_N OUTN 0.35637f
C3 VTHP BW_EN_N 0.14867f
C4 RXP RXN 0.03069f
C5 BW_EN_N VDD 3.18648f
C6 VBIAS RXN 0.35975f
C7 VBIAS RXP 0.89265f
C8 OUTP OUTN 0.06458f
C9 VTHP VTHN 0.71464f
C10 VDD VTHN 0.41959f
C11 OUTP VDD 0.9208f
C12 VDD OUTN 0.9208f
C13 VTHP VDD 0.41959f
C14 RXN VSS 2.11141f
C15 RXP VSS 2.49385f
C16 VBIAS VSS 11.72791f
C17 VTHN VSS 2.64119f
C18 VTHP VSS 2.64146f
C19 BW_EN_N VSS 3.54658f
C20 OUTN VSS 3.6243f
C21 OUTP VSS 3.65845f
C22 VDD VSS 80.80168f
C23 a_n6716_3500.t1 VSS 0.46842f
C24 a_n6716_3500.t0 VSS 0.98964f
C25 a_n6572_3500.t4 VSS 0.5643f
C26 a_n6572_3500.t0 VSS 0.12072f
C27 a_n6572_3500.t1 VSS 0.12076f
C28 a_n6572_3500.n0 VSS 0.18415f
C29 a_n6572_3500.t2 VSS 0.38879f
C30 a_n6572_3500.t3 VSS 0.15509f
C31 a_n6572_3500.n1 VSS 1.38625f
C32 a_n6572_3500.n2 VSS 0.64141f
C33 a_n6572_3500.n3 VSS 0.84248f
C34 a_n6572_3500.n4 VSS 2.72182f
C35 a_n6572_3500.n5 VSS 0.25065f
C36 a_n6572_3500.t5 VSS 0.56439f
C37 a_n3600_5641.t3 VSS 0.53439f
C38 a_n3600_5641.t1 VSS 0.12002f
C39 a_n3600_5641.t2 VSS 0.11998f
C40 a_n3600_5641.n0 VSS 0.18273f
C41 a_n3600_5641.t0 VSS 0.37268f
C42 a_n3600_5641.t5 VSS 0.1539f
C43 a_n3600_5641.n1 VSS 1.37555f
C44 a_n3600_5641.n2 VSS 0.55474f
C45 a_n3600_5641.n3 VSS 1.07214f
C46 a_n3600_5641.n4 VSS 2.44613f
C47 a_n3600_5641.n5 VSS 0.28121f
C48 a_n3600_5641.t4 VSS 0.5343f
C49 a_n1900_5958.t1 VSS 0.5683f
C50 a_n1900_5958.t0 VSS 1.16866f
C51 a_484_3500.t0 VSS 0.56828f
C52 a_484_3500.t1 VSS 1.16862f
C53 a_5300_5958.t0 VSS 0.53702f
C54 a_5300_5958.t1 VSS 1.12205f
C55 a_n5052_2600.t5 VSS 0.03155f
C56 a_n5052_2600.t7 VSS 0.12279f
C57 a_n5052_2600.t4 VSS 0.12279f
C58 a_n5052_2600.t3 VSS 0.048f
C59 a_n5052_2600.t2 VSS 0.04797f
C60 a_n5052_2600.n0 VSS 0.10737f
C61 a_n5052_2600.t1 VSS 0.04797f
C62 a_n5052_2600.t0 VSS 0.048f
C63 a_n5052_2600.n1 VSS 0.10737f
C64 a_n5052_2600.n2 VSS 0.98516f
C65 a_n5052_2600.n3 VSS 0.46257f
C66 a_n5052_2600.n4 VSS 0.09122f
C67 a_n5052_2600.t6 VSS 0.03155f
C68 a_n5052_n1000.t8 VSS 0.16233f
C69 a_n5052_n1000.t6 VSS 0.16179f
C70 a_n5052_n1000.t5 VSS 0.16179f
C71 a_n5052_n1000.n0 VSS 0.45893f
C72 a_n5052_n1000.n1 VSS 0.14951f
C73 a_n5052_n1000.t4 VSS 0.65644f
C74 a_n5052_n1000.n2 VSS 0.13501f
C75 a_n5052_n1000.t1 VSS 0.1791f
C76 a_n5052_n1000.t0 VSS 0.1791f
C77 a_n5052_n1000.n3 VSS 0.50742f
C78 a_n5052_n1000.t2 VSS 0.20537f
C79 a_n5052_n1000.t3 VSS 0.20537f
C80 a_n5052_n1000.n4 VSS 0.50742f
C81 a_n5052_n1000.n5 VSS 1.21852f
C82 a_n5052_n1000.n6 VSS 0.49183f
C83 a_n5052_n1000.n7 VSS 0.11815f
C84 a_n5052_n1000.n8 VSS 0.4607f
C85 a_n5052_n1000.t7 VSS 0.16179f
C86 a_2148_n500.t8 VSS 0.11543f
C87 a_2148_n500.t6 VSS 0.11489f
C88 a_2148_n500.t5 VSS 0.11489f
C89 a_2148_n500.n0 VSS 0.28658f
C90 a_2148_n500.n1 VSS 0.09336f
C91 a_2148_n500.t4 VSS 0.42397f
C92 a_2148_n500.n2 VSS 0.08431f
C93 a_2148_n500.t3 VSS 0.08272f
C94 a_2148_n500.t0 VSS 0.08272f
C95 a_2148_n500.n3 VSS 0.17591f
C96 a_2148_n500.t1 VSS 0.08306f
C97 a_2148_n500.t2 VSS 0.08306f
C98 a_2148_n500.n4 VSS 0.17591f
C99 a_2148_n500.n5 VSS 0.81634f
C100 a_2148_n500.n6 VSS 0.37461f
C101 a_2148_n500.n7 VSS 0.07378f
C102 a_2148_n500.n8 VSS 0.28768f
C103 a_2148_n500.t7 VSS 0.11489f
C104 VSS.t42 VSS 0.03744f
C105 VSS.t40 VSS 0.0369f
C106 VSS.t34 VSS 0.0369f
C107 VSS.t38 VSS 0.0369f
C108 VSS.t36 VSS 0.03744f
C109 VSS.t32 VSS 0.0369f
C110 VSS.t30 VSS 0.0369f
C111 VSS.t16 VSS 0.03744f
C112 VSS.t18 VSS 0.0369f
C113 VSS.t20 VSS 0.03744f
C114 VDD.t3 VSS 1.95466f
C115 VDD.t4 VSS 2.34559f
C116 VDD.t5 VSS 2.34559f
C117 VDD.t6 VSS 1.79601f
C118 VDD.t0 VSS 0.04051f
C119 VDD.n0 VSS 0.60654f
C120 VDD.t2 VSS 0.0502f
C121 VDD.n1 VSS 0.1481f
C122 VDD.t10 VSS 0.0502f
C123 VDD.n2 VSS 0.1481f
C124 VDD.t1 VSS 0.04051f
C125 VDD.n3 VSS 0.13285f
C126 VDD.t9 VSS 0.04249f
C127 VDD.t8 VSS 0.04684f
C128 VDD.n4 VSS 0.28137f
C129 VDD.t11 VSS 0.04684f
C130 VDD.n5 VSS 0.1436f
C131 VDD.t7 VSS 0.04051f
C132 VDD.n6 VSS 0.16045f
C133 OUTP.t3 VSS 0.12632f
C134 OUTP.t2 VSS 0.35752f
C135 OUTP.t1 VSS 0.27173f
C136 OUTP.t0 VSS 0.27182f
C137 OUTP.n0 VSS 0.5353f
C138 OUTP.n1 VSS 1.72676f
C139 OUTN.t2 VSS 0.11968f
C140 OUTN.t3 VSS 0.35626f
C141 OUTN.t0 VSS 0.25951f
C142 OUTN.t1 VSS 0.25943f
C143 OUTN.n0 VSS 0.50717f
C144 OUTN.n1 VSS 1.63601f
C145 BW_EN_N.n0 VSS 2.4144f
C146 BW_EN_N.n1 VSS 2.34855f
C147 VTHP.n0 VSS 0.29178f
C148 VTHN.n0 VSS 0.29178f
C149 VBIAS.n0 VSS 0.03339f
C150 VBIAS.n1 VSS 0.03545f
C151 VBIAS.n2 VSS 0.03545f
C152 VBIAS.n3 VSS 0.03545f
C153 VBIAS.n4 VSS 0.03339f
C154 VBIAS.n5 VSS 0.14438f
C155 VBIAS.n6 VSS 0.0133f
C156 VBIAS.n7 VSS 0.01653f
C157 VBIAS.n8 VSS 0.01653f
C158 VBIAS.n9 VSS 0.0133f
C159 VBIAS.n10 VSS 0.33016f
C160 VBIAS.n11 VSS 0.03339f
C161 VBIAS.n12 VSS 0.03545f
C162 VBIAS.n13 VSS 0.03545f
C163 VBIAS.n14 VSS 0.03545f
C164 VBIAS.n15 VSS 0.03339f
C165 VBIAS.n16 VSS 0.12951f
C166 VBIAS.n17 VSS 0.85897f
C167 RXP.n0 VSS 0.27506f
C168 RXN.n0 VSS 0.18529f
.ends
