* PEX produced using /foss/tools/sak/sak-pex.sh with m=3 and s=1 (extresist threshold=0 mOhm, minres=1 mOhm, mindelay=0 ps)
* NGSPICE file created from cdr_sampler_pex.ext - technology: gf180mcuD

.subckt cdr_sampler_pex DATA_P DATA_N CLK_P CLK_N VBIAS VDD VSS EVEN_P EVEN_N ODD_P
+ ODD_N
X0 EVEN_P.t2 EVEN_N.t5 a_n5652_200.t1 VSS.t6 nfet_03v3 ad=2.64p pd=12.88u as=1.56p ps=6.52u w=6u l=0.28u
X1 a_n6052_n2400.t4 CLK_N.t3 a_n5652_200.t4 VSS.t33 nfet_03v3 ad=2.08p pd=8.52u as=3.52p ps=16.88u w=8u l=0.28u
X2 a_3548_n2400.t6 CLK_P.t1 a_3948_200.t2 VSS.t39 nfet_03v3 ad=2.08p pd=8.52u as=3.52p ps=16.88u w=8u l=0.28u
X3 a_3548_n2400.t3 VBIAS.t0 VSS.t32 VSS.t31 nfet_03v3 ad=4.4p pd=20.88u as=2.6p ps=10.52u w=10u l=0.28u
X4 VSS.t28 VBIAS.t3 a_3548_n2400.t0 VSS.t27 nfet_03v3 ad=2.6p pd=10.52u as=4.4p ps=20.88u w=10u l=0.28u
X5 a_n7252_200.t2 DATA_N.t3 EVEN_P.t3 VSS.t10 nfet_03v3 ad=1.56p pd=6.52u as=2.64p ps=12.88u w=6u l=0.28u
X6 a_n6052_n2400.t1 VBIAS.t6 VSS.t18 VSS.t17 nfet_03v3 ad=2.6p pd=10.52u as=2.6p ps=10.52u w=10u l=0.28u
X7 VDD.t3 ODD_N.t4 VSS.t41 ppolyf_u r_width=2u r_length=5u
X8 VDD.t1 EVEN_N.t2 VSS.t9 ppolyf_u r_width=2u r_length=5u
X9 a_3948_200.t4 ODD_P.t6 ODD_N.t2 VSS.t42 nfet_03v3 ad=1.56p pd=6.52u as=2.64p ps=12.88u w=6u l=0.28u
X10 a_n5652_200.t5 CLK_N.t2 a_n6052_n2400.t5 VSS.t34 nfet_03v3 ad=3.52p pd=16.88u as=2.08p ps=8.52u w=8u l=0.28u
X11 a_2348_200.t5 CLK_N.t0 a_3548_n2400.t5 VSS.t36 nfet_03v3 ad=3.52p pd=16.88u as=2.08p ps=8.52u w=8u l=0.28u
X12 EVEN_N.t4 EVEN_P.t5 a_n5652_200.t3 VSS.t8 nfet_03v3 ad=2.64p pd=12.88u as=1.56p ps=6.52u w=6u l=0.28u
X13 EVEN_N.t0 DATA_P.t2 a_n7252_200.t1 VSS.t2 nfet_03v3 ad=2.64p pd=12.88u as=1.56p ps=6.52u w=6u l=0.28u
X14 VSS.t22 VBIAS.t5 a_n6052_n2400.t2 VSS.t21 nfet_03v3 ad=2.6p pd=10.52u as=2.6p ps=10.52u w=10u l=0.28u
X15 VSS.t30 VBIAS.t1 a_3548_n2400.t2 VSS.t29 nfet_03v3 ad=2.6p pd=10.52u as=2.6p ps=10.52u w=10u l=0.28u
X16 ODD_N.t1 DATA_P.t0 a_2348_200.t1 VSS.t4 nfet_03v3 ad=2.64p pd=12.88u as=1.56p ps=6.52u w=6u l=0.28u
X17 a_n5652_200.t0 EVEN_N.t6 EVEN_P.t1 VSS.t5 nfet_03v3 ad=1.56p pd=6.52u as=2.64p ps=12.88u w=6u l=0.28u
X18 a_3548_n2400.t4 CLK_N.t1 a_2348_200.t4 VSS.t35 nfet_03v3 ad=2.08p pd=8.52u as=3.52p ps=16.88u w=8u l=0.28u
X19 VDD.t0 EVEN_P.t0 VSS.t0 ppolyf_u r_width=2u r_length=5u
X20 a_n5652_200.t2 EVEN_P.t6 EVEN_N.t3 VSS.t7 nfet_03v3 ad=1.56p pd=6.52u as=2.64p ps=12.88u w=6u l=0.28u
X21 VSS.t20 VBIAS.t7 a_n6052_n2400.t0 VSS.t19 nfet_03v3 ad=2.6p pd=10.52u as=4.4p ps=20.88u w=10u l=0.28u
X22 a_3948_200.t0 ODD_N.t6 ODD_P.t3 VSS.t15 nfet_03v3 ad=1.56p pd=6.52u as=2.64p ps=12.88u w=6u l=0.28u
X23 a_n6052_n2400.t7 CLK_P.t3 a_n7252_200.t4 VSS.t37 nfet_03v3 ad=2.08p pd=8.52u as=3.52p ps=16.88u w=8u l=0.28u
X24 a_2348_200.t2 DATA_N.t1 ODD_P.t1 VSS.t12 nfet_03v3 ad=1.56p pd=6.52u as=2.64p ps=12.88u w=6u l=0.28u
X25 a_n6052_n2400.t3 VBIAS.t4 VSS.t26 VSS.t25 nfet_03v3 ad=4.4p pd=20.88u as=2.6p ps=10.52u w=10u l=0.28u
X26 a_3548_n2400.t1 VBIAS.t2 VSS.t24 VSS.t23 nfet_03v3 ad=2.6p pd=10.52u as=2.6p ps=10.52u w=10u l=0.28u
X27 ODD_N.t3 ODD_P.t5 a_3948_200.t5 VSS.t43 nfet_03v3 ad=2.64p pd=12.88u as=1.56p ps=6.52u w=6u l=0.28u
X28 ODD_P.t4 ODD_N.t5 a_3948_200.t1 VSS.t16 nfet_03v3 ad=2.64p pd=12.88u as=1.56p ps=6.52u w=6u l=0.28u
X29 EVEN_P.t4 DATA_N.t2 a_n7252_200.t3 VSS.t11 nfet_03v3 ad=2.64p pd=12.88u as=1.56p ps=6.52u w=6u l=0.28u
X30 a_3948_200.t3 CLK_P.t0 a_3548_n2400.t7 VSS.t40 nfet_03v3 ad=3.52p pd=16.88u as=2.08p ps=8.52u w=8u l=0.28u
X31 a_n7252_200.t0 DATA_P.t3 EVEN_N.t1 VSS.t1 nfet_03v3 ad=1.56p pd=6.52u as=2.64p ps=12.88u w=6u l=0.28u
X32 a_n7252_200.t5 CLK_P.t2 a_n6052_n2400.t6 VSS.t38 nfet_03v3 ad=3.52p pd=16.88u as=2.08p ps=8.52u w=8u l=0.28u
X33 a_2348_200.t0 DATA_P.t1 ODD_N.t0 VSS.t3 nfet_03v3 ad=1.56p pd=6.52u as=2.64p ps=12.88u w=6u l=0.28u
X34 VDD.t2 ODD_P.t2 VSS.t14 ppolyf_u r_width=2u r_length=5u
X35 ODD_P.t0 DATA_N.t0 a_2348_200.t3 VSS.t13 nfet_03v3 ad=2.64p pd=12.88u as=1.56p ps=6.52u w=6u l=0.28u
R0 VBIAS.n3 VBIAS.t3 139.702
R1 VBIAS.n0 VBIAS.t0 139.702
R2 VBIAS.n5 VBIAS.t4 139.702
R3 VBIAS.n8 VBIAS.t7 139.702
R4 VBIAS.n1 VBIAS.t1 135.246
R5 VBIAS.n2 VBIAS.t2 135.246
R6 VBIAS.n6 VBIAS.t5 135.246
R7 VBIAS.n7 VBIAS.t6 135.246
R8 VBIAS.n10 VBIAS.n4 19.1847
R9 VBIAS.n10 VBIAS.n9 13.5005
R10 VBIAS.n2 VBIAS.n1 11.6805
R11 VBIAS.n7 VBIAS.n6 11.6805
R12 VBIAS.n4 VBIAS.n0 7.10487
R13 VBIAS.n4 VBIAS.n3 7.10487
R14 VBIAS.n9 VBIAS.n5 7.10487
R15 VBIAS.n9 VBIAS.n8 7.10487
R16 VBIAS.n1 VBIAS.n0 4.42851
R17 VBIAS.n3 VBIAS.n2 4.42851
R18 VBIAS.n6 VBIAS.n5 4.42851
R19 VBIAS.n8 VBIAS.n7 4.42851
R20 VBIAS.n11 VBIAS.n10 1.30313
R21 VBIAS.n11 VBIAS 0.109447
R22 VBIAS VBIAS.n11 0.0455
R23 CLK_N.n1 CLK_N.t1 113.618
R24 CLK_N.n1 CLK_N.t0 113.618
R25 CLK_N.n0 CLK_N.t3 113.618
R26 CLK_N.n0 CLK_N.t2 113.618
R27 CLK_N.n2 CLK_N.n1 25.1703
R28 CLK_N.n2 CLK_N.n0 20.9071
R29 CLK_N CLK_N.n2 3.27129
R30 CLK_P.n1 CLK_P.t1 113.618
R31 CLK_P.n1 CLK_P.t0 113.618
R32 CLK_P.n0 CLK_P.t3 113.618
R33 CLK_P.n0 CLK_P.t2 113.618
R34 CLK_P.n2 CLK_P.n1 28.3203
R35 CLK_P.n2 CLK_P.n0 25.1624
R36 CLK_P CLK_P.n2 0.9805
R37 DATA_P.n0 DATA_P.t1 87.5461
R38 DATA_P.n0 DATA_P.t0 87.5461
R39 DATA_P.n1 DATA_P.t3 87.5461
R40 DATA_P.n1 DATA_P.t2 87.5461
R41 DATA_P.n2 DATA_P.n0 31.2488
R42 DATA_P.n2 DATA_P.n1 25.5646
R43 DATA_P DATA_P.n2 13.7768
R44 DATA_N.n1 DATA_N.t1 87.5461
R45 DATA_N.n1 DATA_N.t0 87.5461
R46 DATA_N.n0 DATA_N.t3 87.5461
R47 DATA_N.n0 DATA_N.t2 87.5461
R48 DATA_N.n2 DATA_N.n1 22.0262
R49 DATA_N.n2 DATA_N.n0 16.342
R50 DATA_N DATA_N.n2 8.23076
R51 ODD_N.n1 ODD_N.t5 87.5461
R52 ODD_N.n1 ODD_N.t6 87.5461
R53 ODD_N.n2 ODD_N.n1 26.3217
R54 ODD_N ODD_N.t4 12.5596
R55 ODD_N.n0 ODD_N.t1 5.96544
R56 ODD_N.n0 ODD_N.t0 5.9622
R57 ODD_N.n5 ODD_N.t3 5.87051
R58 ODD_N.n4 ODD_N.t2 5.87051
R59 ODD_N.n4 ODD_N.n3 4.5005
R60 ODD_N.n6 ODD_N.n5 4.5005
R61 ODD_N.n8 ODD_N.n0 2.56391
R62 ODD_N ODD_N.n8 0.7805
R63 ODD_N.n7 ODD_N.n2 0.419
R64 ODD_N.n8 ODD_N.n7 0.2415
R65 ODD_N.n5 ODD_N.n4 0.189974
R66 ODD_N.n6 ODD_N.n3 0.1605
R67 ODD_N.n7 ODD_N.n6 0.0795
R68 ODD_N.n3 ODD_N.n2 0.0740593
R69 ODD_P.n0 ODD_P.t5 87.5461
R70 ODD_P.n0 ODD_P.t6 87.5461
R71 ODD_P.n1 ODD_P.n0 35.3132
R72 ODD_P ODD_P.t2 12.5596
R73 ODD_P.n7 ODD_P.t1 5.96544
R74 ODD_P.n7 ODD_P.t0 5.9622
R75 ODD_P.n3 ODD_P.t4 5.87051
R76 ODD_P.n4 ODD_P.t3 5.87051
R77 ODD_P.n5 ODD_P.n4 4.5005
R78 ODD_P.n3 ODD_P.n2 4.5005
R79 ODD_P.n8 ODD_P.n7 2.56391
R80 ODD_P ODD_P.n8 0.7805
R81 ODD_P.n6 ODD_P.n1 0.419
R82 ODD_P.n8 ODD_P.n6 0.2415
R83 ODD_P.n4 ODD_P.n3 0.189974
R84 ODD_P.n5 ODD_P.n2 0.1605
R85 ODD_P.n6 ODD_P.n5 0.0795
R86 ODD_P.n2 ODD_P.n1 0.0405
R87 EVEN_N.n1 EVEN_N.t5 87.5461
R88 EVEN_N.n1 EVEN_N.t6 87.5461
R89 EVEN_N.n2 EVEN_N.n1 26.3484
R90 EVEN_N EVEN_N.t2 12.5596
R91 EVEN_N.n0 EVEN_N.t0 5.96544
R92 EVEN_N.n0 EVEN_N.t1 5.9622
R93 EVEN_N.n5 EVEN_N.t4 5.87051
R94 EVEN_N.n4 EVEN_N.t3 5.87051
R95 EVEN_N.n4 EVEN_N.n3 4.5005
R96 EVEN_N.n6 EVEN_N.n5 4.5005
R97 EVEN_N.n8 EVEN_N.n0 2.56391
R98 EVEN_N EVEN_N.n8 0.7805
R99 EVEN_N.n7 EVEN_N.n2 0.419
R100 EVEN_N.n8 EVEN_N.n7 0.2415
R101 EVEN_N.n5 EVEN_N.n4 0.189974
R102 EVEN_N.n6 EVEN_N.n3 0.1605
R103 EVEN_N.n7 EVEN_N.n6 0.0795
R104 EVEN_N.n3 EVEN_N.n2 0.0405
R105 EVEN_P.n0 EVEN_P.t5 87.5461
R106 EVEN_P.n0 EVEN_P.t6 87.5461
R107 EVEN_P.n1 EVEN_P.n0 35.155
R108 EVEN_P EVEN_P.t0 12.5596
R109 EVEN_P.n7 EVEN_P.t3 5.96544
R110 EVEN_P.n7 EVEN_P.t4 5.9622
R111 EVEN_P.n3 EVEN_P.t2 5.87051
R112 EVEN_P.n4 EVEN_P.t1 5.87051
R113 EVEN_P.n5 EVEN_P.n4 4.5005
R114 EVEN_P.n3 EVEN_P.n2 4.5005
R115 EVEN_P.n8 EVEN_P.n7 2.56391
R116 EVEN_P EVEN_P.n8 0.7805
R117 EVEN_P.n6 EVEN_P.n1 0.419
R118 EVEN_P.n8 EVEN_P.n6 0.2415
R119 EVEN_P.n4 EVEN_P.n3 0.189974
R120 EVEN_P.n5 EVEN_P.n2 0.1605
R121 EVEN_P.n6 EVEN_P.n5 0.0795
R122 EVEN_P.n2 EVEN_P.n1 0.0740593
R123 VDD.n1 VDD.t0 22.1461
R124 VDD.n0 VDD.t3 22.1461
R125 VDD.n1 VDD.t1 21.435
R126 VDD.n0 VDD.t2 21.435
R127 VDD VDD.n0 0.756056
R128 VDD VDD.n1 0.667167
R129 VSS.n139 VSS.n4 354.546
R130 VSS.n96 VSS.n95 354.546
R131 VSS.n96 VSS.n24 354.546
R132 VSS.n89 VSS.n24 354.546
R133 VSS.n68 VSS.n67 354.546
R134 VSS.n139 VSS.n138 153.637
R135 VSS.t10 VSS.n4 153.637
R136 VSS.n95 VSS.t2 153.637
R137 VSS.n89 VSS.t12 153.637
R138 VSS.n67 VSS.t4 153.637
R139 VSS.n68 VSS.n40 153.637
R140 VSS.n113 VSS.t11 107.546
R141 VSS.t1 VSS.n17 107.546
R142 VSS.n81 VSS.t13 107.546
R143 VSS.t3 VSS.n34 107.546
R144 VSS.n111 VSS.t19 106.365
R145 VSS.n20 VSS.t25 106.365
R146 VSS.n83 VSS.t27 106.365
R147 VSS.n35 VSS.t31 106.365
R148 VSS.t37 VSS.t0 94.546
R149 VSS.t34 VSS.t9 94.546
R150 VSS.t14 VSS.t35 94.546
R151 VSS.t41 VSS.t40 94.546
R152 VSS.t38 VSS.t5 70.9096
R153 VSS.t8 VSS.t33 70.9096
R154 VSS.t15 VSS.t36 70.9096
R155 VSS.t39 VSS.t43 70.9096
R156 VSS.n114 VSS.t0 59.0914
R157 VSS.n104 VSS.t9 59.0914
R158 VSS.n80 VSS.t14 59.0914
R159 VSS.n74 VSS.t41 59.0914
R160 VSS.n140 VSS.n2 52.5005
R161 VSS.n13 VSS.n2 52.5005
R162 VSS.n110 VSS.n13 52.5005
R163 VSS.n110 VSS.n14 52.5005
R164 VSS.n105 VSS.n14 52.5005
R165 VSS.n105 VSS.n16 52.5005
R166 VSS.n94 VSS.n16 52.5005
R167 VSS.n94 VSS.n25 52.5005
R168 VSS.n90 VSS.n25 52.5005
R169 VSS.n90 VSS.n27 52.5005
R170 VSS.n79 VSS.n27 52.5005
R171 VSS.n79 VSS.n31 52.5005
R172 VSS.n75 VSS.n31 52.5005
R173 VSS.n75 VSS.n33 52.5005
R174 VSS.n66 VSS.n33 52.5005
R175 VSS.n125 VSS.n124 52.5005
R176 VSS.n129 VSS.n128 52.5005
R177 VSS.n133 VSS.n132 52.5005
R178 VSS.n137 VSS.n10 52.5005
R179 VSS.n116 VSS.n5 52.5005
R180 VSS.n116 VSS.n115 52.5005
R181 VSS.n115 VSS.n12 52.5005
R182 VSS.n21 VSS.n12 52.5005
R183 VSS.n103 VSS.n21 52.5005
R184 VSS.n103 VSS.n18 52.5005
R185 VSS.n97 VSS.n18 52.5005
R186 VSS.n97 VSS.n23 52.5005
R187 VSS.n88 VSS.n23 52.5005
R188 VSS.n88 VSS.n28 52.5005
R189 VSS.n84 VSS.n28 52.5005
R190 VSS.n84 VSS.n30 52.5005
R191 VSS.n73 VSS.n30 52.5005
R192 VSS.n73 VSS.n37 52.5005
R193 VSS.n69 VSS.n37 52.5005
R194 VSS.n58 VSS.n56 52.5005
R195 VSS.n54 VSS.n43 52.5005
R196 VSS.n50 VSS.n48 52.5005
R197 VSS.n48 VSS.n47 52.5005
R198 VSS.n140 VSS.n3 50.7505
R199 VSS.n66 VSS.n41 50.7505
R200 VSS.t11 VSS.t10 47.2732
R201 VSS.t5 VSS.t6 47.2732
R202 VSS.t17 VSS.t19 47.2732
R203 VSS.t21 VSS.t17 47.2732
R204 VSS.t25 VSS.t21 47.2732
R205 VSS.t7 VSS.t8 47.2732
R206 VSS.t2 VSS.t1 47.2732
R207 VSS.t13 VSS.t12 47.2732
R208 VSS.t16 VSS.t15 47.2732
R209 VSS.t23 VSS.t27 47.2732
R210 VSS.t29 VSS.t23 47.2732
R211 VSS.t31 VSS.t29 47.2732
R212 VSS.t43 VSS.t42 47.2732
R213 VSS.t4 VSS.t3 47.2732
R214 VSS.n114 VSS.n113 46.0914
R215 VSS.n104 VSS.n17 46.0914
R216 VSS.n81 VSS.n80 46.0914
R217 VSS.n74 VSS.n34 46.0914
R218 VSS.n137 VSS.n5 42.0005
R219 VSS.n69 VSS.n39 42.0005
R220 VSS.n112 VSS.t38 36.6369
R221 VSS.t33 VSS.n19 36.6369
R222 VSS.t36 VSS.n82 36.6369
R223 VSS.n36 VSS.t39 36.6369
R224 VSS.t6 VSS.n111 35.455
R225 VSS.n20 VSS.t7 35.455
R226 VSS.n83 VSS.t16 35.455
R227 VSS.t42 VSS.n35 35.455
R228 VSS VSS.n142 19.0449
R229 VSS.n63 VSS.n62 13.5139
R230 VSS.n122 VSS.n121 13.5139
R231 VSS.n112 VSS.t37 10.6369
R232 VSS.n19 VSS.t34 10.6369
R233 VSS.n82 VSS.t35 10.6369
R234 VSS.t40 VSS.n36 10.6369
R235 VSS.n62 VSS.n60 6.38826
R236 VSS.n121 VSS.n120 6.38826
R237 VSS.n62 VSS.n61 6.38502
R238 VSS.n121 VSS.n119 6.38502
R239 VSS.n138 VSS.n137 5.2005
R240 VSS.n137 VSS.n136 5.2005
R241 VSS.n135 VSS.n10 5.2005
R242 VSS.n134 VSS.n133 5.2005
R243 VSS.n132 VSS.n131 5.2005
R244 VSS.n130 VSS.n129 5.2005
R245 VSS.n128 VSS.n127 5.2005
R246 VSS.n126 VSS.n125 5.2005
R247 VSS.n124 VSS.n123 5.2005
R248 VSS.n3 VSS.n0 5.2005
R249 VSS.n139 VSS.n5 5.2005
R250 VSS.n118 VSS.n5 5.2005
R251 VSS.n116 VSS.n4 5.2005
R252 VSS.n117 VSS.n116 5.2005
R253 VSS.n115 VSS.n114 5.2005
R254 VSS.n115 VSS.n11 5.2005
R255 VSS.n111 VSS.n12 5.2005
R256 VSS.n100 VSS.n12 5.2005
R257 VSS.n21 VSS.n20 5.2005
R258 VSS.n101 VSS.n21 5.2005
R259 VSS.n104 VSS.n103 5.2005
R260 VSS.n103 VSS.n102 5.2005
R261 VSS.n95 VSS.n18 5.2005
R262 VSS.n99 VSS.n18 5.2005
R263 VSS.n97 VSS.n96 5.2005
R264 VSS.n98 VSS.n97 5.2005
R265 VSS.n24 VSS.n23 5.2005
R266 VSS.n23 VSS.n22 5.2005
R267 VSS.n89 VSS.n88 5.2005
R268 VSS.n88 VSS.n87 5.2005
R269 VSS.n80 VSS.n28 5.2005
R270 VSS.n86 VSS.n28 5.2005
R271 VSS.n84 VSS.n83 5.2005
R272 VSS.n85 VSS.n84 5.2005
R273 VSS.n35 VSS.n30 5.2005
R274 VSS.n30 VSS.n29 5.2005
R275 VSS.n74 VSS.n73 5.2005
R276 VSS.n73 VSS.n72 5.2005
R277 VSS.n67 VSS.n37 5.2005
R278 VSS.n71 VSS.n37 5.2005
R279 VSS.n69 VSS.n68 5.2005
R280 VSS.n70 VSS.n69 5.2005
R281 VSS.n64 VSS.n41 5.2005
R282 VSS.n59 VSS.n58 5.2005
R283 VSS.n56 VSS.n42 5.2005
R284 VSS.n54 VSS.n53 5.2005
R285 VSS.n52 VSS.n43 5.2005
R286 VSS.n51 VSS.n50 5.2005
R287 VSS.n48 VSS.n40 5.2005
R288 VSS.n48 VSS.n44 5.2005
R289 VSS.n47 VSS.n45 5.2005
R290 VSS.n39 VSS.n38 5.2005
R291 VSS.n68 VSS.n66 5.2005
R292 VSS.n66 VSS.n65 5.2005
R293 VSS.n67 VSS.n33 5.2005
R294 VSS.n33 VSS.n32 5.2005
R295 VSS.n75 VSS.n74 5.2005
R296 VSS.n76 VSS.n75 5.2005
R297 VSS.n35 VSS.n31 5.2005
R298 VSS.n77 VSS.n31 5.2005
R299 VSS.n83 VSS.n79 5.2005
R300 VSS.n79 VSS.n78 5.2005
R301 VSS.n80 VSS.n27 5.2005
R302 VSS.n27 VSS.n26 5.2005
R303 VSS.n90 VSS.n89 5.2005
R304 VSS.n91 VSS.n90 5.2005
R305 VSS.n25 VSS.n24 5.2005
R306 VSS.n92 VSS.n25 5.2005
R307 VSS.n96 VSS.n94 5.2005
R308 VSS.n94 VSS.n93 5.2005
R309 VSS.n95 VSS.n16 5.2005
R310 VSS.n16 VSS.n15 5.2005
R311 VSS.n105 VSS.n104 5.2005
R312 VSS.n106 VSS.n105 5.2005
R313 VSS.n20 VSS.n14 5.2005
R314 VSS.n107 VSS.n14 5.2005
R315 VSS.n111 VSS.n110 5.2005
R316 VSS.n110 VSS.n109 5.2005
R317 VSS.n114 VSS.n13 5.2005
R318 VSS.n108 VSS.n13 5.2005
R319 VSS.n4 VSS.n2 5.2005
R320 VSS.n2 VSS.n1 5.2005
R321 VSS.n140 VSS.n139 5.2005
R322 VSS.n141 VSS.n140 5.2005
R323 VSS.n10 VSS.n9 4.34122
R324 VSS.n132 VSS.n8 4.34122
R325 VSS.n128 VSS.n7 4.34122
R326 VSS.n124 VSS.n6 4.34122
R327 VSS.n57 VSS.n41 4.34122
R328 VSS.n56 VSS.n55 4.34122
R329 VSS.n49 VSS.n43 4.34122
R330 VSS.n47 VSS.n46 4.34122
R331 VSS.n6 VSS.n3 4.34122
R332 VSS.n125 VSS.n7 4.34122
R333 VSS.n129 VSS.n8 4.34122
R334 VSS.n133 VSS.n9 4.34122
R335 VSS.n58 VSS.n57 4.34122
R336 VSS.n55 VSS.n54 4.34122
R337 VSS.n50 VSS.n49 4.34122
R338 VSS.n46 VSS.n39 4.34122
R339 VSS.n36 VSS.n34 3.54389
R340 VSS.n82 VSS.n81 3.54389
R341 VSS.n19 VSS.n17 3.54389
R342 VSS.n113 VSS.n112 3.54389
R343 VSS.n126 VSS.n123 0.6755
R344 VSS.n127 VSS.n126 0.6755
R345 VSS.n130 VSS.n127 0.6755
R346 VSS.n131 VSS.n130 0.6755
R347 VSS.n134 VSS.n131 0.6755
R348 VSS.n135 VSS.n134 0.6755
R349 VSS.n136 VSS.n135 0.6755
R350 VSS.n118 VSS.n117 0.6755
R351 VSS.n117 VSS.n11 0.6755
R352 VSS.n100 VSS.n11 0.6755
R353 VSS.n101 VSS.n100 0.6755
R354 VSS.n102 VSS.n101 0.6755
R355 VSS.n102 VSS.n99 0.6755
R356 VSS.n99 VSS.n98 0.6755
R357 VSS.n98 VSS.n22 0.6755
R358 VSS.n87 VSS.n22 0.6755
R359 VSS.n87 VSS.n86 0.6755
R360 VSS.n86 VSS.n85 0.6755
R361 VSS.n85 VSS.n29 0.6755
R362 VSS.n72 VSS.n29 0.6755
R363 VSS.n72 VSS.n71 0.6755
R364 VSS.n71 VSS.n70 0.6755
R365 VSS.n59 VSS.n42 0.6755
R366 VSS.n53 VSS.n42 0.6755
R367 VSS.n53 VSS.n52 0.6755
R368 VSS.n52 VSS.n51 0.6755
R369 VSS.n51 VSS.n44 0.6755
R370 VSS.n45 VSS.n44 0.6755
R371 VSS.n45 VSS.n38 0.6755
R372 VSS.n141 VSS.n1 0.6755
R373 VSS.n108 VSS.n1 0.6755
R374 VSS.n109 VSS.n108 0.6755
R375 VSS.n109 VSS.n107 0.6755
R376 VSS.n107 VSS.n106 0.6755
R377 VSS.n106 VSS.n15 0.6755
R378 VSS.n93 VSS.n15 0.6755
R379 VSS.n93 VSS.n92 0.6755
R380 VSS.n92 VSS.n91 0.6755
R381 VSS.n91 VSS.n26 0.6755
R382 VSS.n78 VSS.n26 0.6755
R383 VSS.n78 VSS.n77 0.6755
R384 VSS.n77 VSS.n76 0.6755
R385 VSS.n76 VSS.n32 0.6755
R386 VSS.n65 VSS.n32 0.6755
R387 VSS.n65 VSS.n64 0.653
R388 VSS.n123 VSS.n122 0.563
R389 VSS.n63 VSS.n59 0.563
R390 VSS.n136 VSS.n118 0.5405
R391 VSS.n70 VSS.n38 0.5405
R392 VSS.n138 VSS.n9 0.430889
R393 VSS.n138 VSS.n8 0.430889
R394 VSS.n138 VSS.n7 0.430889
R395 VSS.n138 VSS.n6 0.430889
R396 VSS.n57 VSS.n40 0.430889
R397 VSS.n55 VSS.n40 0.430889
R398 VSS.n49 VSS.n40 0.430889
R399 VSS.n46 VSS.n40 0.430889
R400 VSS.n142 VSS.n141 0.37175
R401 VSS.n142 VSS.n0 0.28175
R402 VSS.n61 VSS.t30 0.1643
R403 VSS.n61 VSS.t32 0.1643
R404 VSS.n60 VSS.t28 0.1643
R405 VSS.n60 VSS.t24 0.1643
R406 VSS.n120 VSS.t22 0.1643
R407 VSS.n120 VSS.t26 0.1643
R408 VSS.n119 VSS.t20 0.1643
R409 VSS.n119 VSS.t18 0.1643
R410 VSS.n122 VSS.n0 0.113
R411 VSS.n64 VSS.n63 0.113
R412 a_3548_n2400.n5 a_3548_n2400.n3 10.7791
R413 a_3548_n2400.n5 a_3548_n2400.n4 10.7791
R414 a_3548_n2400.t3 a_3548_n2400.n7 6.55182
R415 a_3548_n2400.n2 a_3548_n2400.t0 6.45713
R416 a_3548_n2400.n1 a_3548_n2400.n0 6.29333
R417 a_3548_n2400.n6 a_3548_n2400.n2 4.63668
R418 a_3548_n2400.n7 a_3548_n2400.n6 2.23814
R419 a_3548_n2400.n6 a_3548_n2400.n5 0.3305
R420 a_3548_n2400.n3 a_3548_n2400.t6 0.20525
R421 a_3548_n2400.n3 a_3548_n2400.t7 0.20525
R422 a_3548_n2400.n4 a_3548_n2400.t4 0.20525
R423 a_3548_n2400.n4 a_3548_n2400.t5 0.20525
R424 a_3548_n2400.n2 a_3548_n2400.n1 0.189974
R425 a_3548_n2400.n0 a_3548_n2400.t1 0.1643
R426 a_3548_n2400.n0 a_3548_n2400.t2 0.1643
R427 a_3548_n2400.n7 a_3548_n2400.n1 0.0924286
R428 a_n6052_n2400.n5 a_n6052_n2400.n3 10.7791
R429 a_n6052_n2400.n5 a_n6052_n2400.n4 10.7791
R430 a_n6052_n2400.t3 a_n6052_n2400.n7 6.55182
R431 a_n6052_n2400.n2 a_n6052_n2400.t0 6.45713
R432 a_n6052_n2400.n1 a_n6052_n2400.n0 6.29333
R433 a_n6052_n2400.n6 a_n6052_n2400.n2 4.63668
R434 a_n6052_n2400.n7 a_n6052_n2400.n6 2.23814
R435 a_n6052_n2400.n6 a_n6052_n2400.n5 0.3305
R436 a_n6052_n2400.n3 a_n6052_n2400.t4 0.20525
R437 a_n6052_n2400.n3 a_n6052_n2400.t5 0.20525
R438 a_n6052_n2400.n4 a_n6052_n2400.t7 0.20525
R439 a_n6052_n2400.n4 a_n6052_n2400.t6 0.20525
R440 a_n6052_n2400.n2 a_n6052_n2400.n1 0.189974
R441 a_n6052_n2400.n0 a_n6052_n2400.t1 0.1643
R442 a_n6052_n2400.n0 a_n6052_n2400.t2 0.1643
R443 a_n6052_n2400.n7 a_n6052_n2400.n1 0.0924286
R444 a_3948_200.n2 a_3948_200.n0 15.3662
R445 a_3948_200.n2 a_3948_200.n1 14.5662
R446 a_3948_200.n3 a_3948_200.n2 7.70696
R447 a_3948_200.n3 a_3948_200.t2 5.9772
R448 a_3948_200.t3 a_3948_200.n3 5.9772
R449 a_3948_200.n0 a_3948_200.t1 0.2735
R450 a_3948_200.n0 a_3948_200.t0 0.2735
R451 a_3948_200.n1 a_3948_200.t5 0.2735
R452 a_3948_200.n1 a_3948_200.t4 0.2735
R453 a_2348_200.n2 a_2348_200.n0 19.8662
R454 a_2348_200.n2 a_2348_200.n1 19.3329
R455 a_2348_200.n3 a_2348_200.n2 11.5875
R456 a_2348_200.n3 a_2348_200.t5 5.9772
R457 a_2348_200.t4 a_2348_200.n3 5.9772
R458 a_2348_200.n1 a_2348_200.t3 0.2735
R459 a_2348_200.n1 a_2348_200.t2 0.2735
R460 a_2348_200.n0 a_2348_200.t1 0.2735
R461 a_2348_200.n0 a_2348_200.t0 0.2735
R462 a_n5652_200.n2 a_n5652_200.n0 15.3662
R463 a_n5652_200.n2 a_n5652_200.n1 14.5662
R464 a_n5652_200.n3 a_n5652_200.n2 7.70696
R465 a_n5652_200.n3 a_n5652_200.t5 5.9772
R466 a_n5652_200.t4 a_n5652_200.n3 5.9772
R467 a_n5652_200.n0 a_n5652_200.t1 0.2735
R468 a_n5652_200.n0 a_n5652_200.t0 0.2735
R469 a_n5652_200.n1 a_n5652_200.t3 0.2735
R470 a_n5652_200.n1 a_n5652_200.t2 0.2735
R471 a_n7252_200.n2 a_n7252_200.n0 19.8662
R472 a_n7252_200.n2 a_n7252_200.n1 19.3329
R473 a_n7252_200.n3 a_n7252_200.n2 11.5875
R474 a_n7252_200.n3 a_n7252_200.t5 5.9772
R475 a_n7252_200.t4 a_n7252_200.n3 5.9772
R476 a_n7252_200.n1 a_n7252_200.t3 0.2735
R477 a_n7252_200.n1 a_n7252_200.t2 0.2735
R478 a_n7252_200.n0 a_n7252_200.t1 0.2735
R479 a_n7252_200.n0 a_n7252_200.t0 0.2735
C0 EVEN_P EVEN_N 0.97809f
C1 VBIAS CLK_N 0.66536f
C2 CLK_P CLK_N 1.88251f
C3 DATA_N CLK_N 0.09294f
C4 DATA_P CLK_P 0.38527f
C5 DATA_P DATA_N 3.67483f
C6 DATA_P ODD_N 0.21629f
C7 ODD_P DATA_P 0.10098f
C8 EVEN_N VDD 0.04105f
C9 EVEN_N DATA_N 0.21698f
C10 EVEN_P VDD 0.04105f
C11 DATA_P CLK_N 0.02351f
C12 EVEN_P DATA_N 0.42621f
C13 VBIAS CLK_P 0.06377f
C14 DATA_P EVEN_N 0.17266f
C15 ODD_N VDD 0.04105f
C16 EVEN_P DATA_P 0.05468f
C17 ODD_P VDD 0.04105f
C18 ODD_N DATA_N 0.01966f
C19 ODD_P DATA_N 0.17429f
C20 ODD_P ODD_N 1.05177f
C21 VBIAS VSS 6.82479f
C22 CLK_N VSS 5.42278f
C23 CLK_P VSS 6.7188f
C24 DATA_P VSS 7.74183f
C25 DATA_N VSS 6.36008f
C26 ODD_N VSS 5.06665f
C27 ODD_P VSS 5.21383f
C28 EVEN_N VSS 5.00311f
C29 EVEN_P VSS 5.06958f
C30 VDD VSS 10.90022f
C31 a_n7252_200.t5 VSS 0.6432f
C32 a_n7252_200.t1 VSS 0.13839f
C33 a_n7252_200.t0 VSS 0.13839f
C34 a_n7252_200.n0 VSS 0.51748f
C35 a_n7252_200.t3 VSS 0.13977f
C36 a_n7252_200.t2 VSS 0.13977f
C37 a_n7252_200.n1 VSS 0.47972f
C38 a_n7252_200.n2 VSS 3.66238f
C39 a_n7252_200.n3 VSS 0.5066f
C40 a_n7252_200.t4 VSS 0.6432f
C41 a_n5652_200.t5 VSS 0.86185f
C42 a_n5652_200.t1 VSS 0.17508f
C43 a_n5652_200.t0 VSS 0.17508f
C44 a_n5652_200.n0 VSS 0.62947f
C45 a_n5652_200.t3 VSS 0.17664f
C46 a_n5652_200.t2 VSS 0.17664f
C47 a_n5652_200.n1 VSS 0.59102f
C48 a_n5652_200.n2 VSS 2.81843f
C49 a_n5652_200.n3 VSS 0.69295f
C50 a_n5652_200.t4 VSS 0.86185f
C51 a_2348_200.t5 VSS 0.63305f
C52 a_2348_200.t1 VSS 0.13562f
C53 a_2348_200.t0 VSS 0.13562f
C54 a_2348_200.n0 VSS 0.50159f
C55 a_2348_200.t3 VSS 0.13699f
C56 a_2348_200.t2 VSS 0.13699f
C57 a_2348_200.n1 VSS 0.46499f
C58 a_2348_200.n2 VSS 3.54993f
C59 a_2348_200.n3 VSS 0.49105f
C60 a_2348_200.t4 VSS 0.63305f
C61 a_3948_200.t2 VSS 0.8447f
C62 a_3948_200.t1 VSS 0.17417f
C63 a_3948_200.t0 VSS 0.17417f
C64 a_3948_200.n0 VSS 0.62261f
C65 a_3948_200.t5 VSS 0.17272f
C66 a_3948_200.t4 VSS 0.17272f
C67 a_3948_200.n1 VSS 0.58458f
C68 a_3948_200.n2 VSS 2.78771f
C69 a_3948_200.n3 VSS 0.6854f
C70 a_3948_200.t3 VSS 0.8447f
C71 a_n6052_n2400.t2 VSS 0.13585f
C72 a_n6052_n2400.t1 VSS 0.13585f
C73 a_n6052_n2400.n0 VSS 0.41005f
C74 a_n6052_n2400.n1 VSS 0.13359f
C75 a_n6052_n2400.t0 VSS 0.57768f
C76 a_n6052_n2400.n2 VSS 0.11951f
C77 a_n6052_n2400.t5 VSS 0.13967f
C78 a_n6052_n2400.t4 VSS 0.13967f
C79 a_n6052_n2400.n3 VSS 0.38158f
C80 a_n6052_n2400.t6 VSS 0.13136f
C81 a_n6052_n2400.t7 VSS 0.13136f
C82 a_n6052_n2400.n4 VSS 0.38158f
C83 a_n6052_n2400.n5 VSS 1.1703f
C84 a_n6052_n2400.n6 VSS 0.35278f
C85 a_n6052_n2400.n7 VSS 0.11778f
C86 a_n6052_n2400.t3 VSS 0.57941f
C87 a_3548_n2400.t2 VSS 0.13263f
C88 a_3548_n2400.t1 VSS 0.13263f
C89 a_3548_n2400.n0 VSS 0.39821f
C90 a_3548_n2400.n1 VSS 0.12973f
C91 a_3548_n2400.t0 VSS 0.56171f
C92 a_3548_n2400.n2 VSS 0.11606f
C93 a_3548_n2400.t7 VSS 0.12879f
C94 a_3548_n2400.t6 VSS 0.12879f
C95 a_3548_n2400.n3 VSS 0.37057f
C96 a_3548_n2400.t5 VSS 0.13709f
C97 a_3548_n2400.t4 VSS 0.13709f
C98 a_3548_n2400.n4 VSS 0.37057f
C99 a_3548_n2400.n5 VSS 1.13651f
C100 a_3548_n2400.n6 VSS 0.3426f
C101 a_3548_n2400.n7 VSS 0.11438f
C102 a_3548_n2400.t3 VSS 0.56339f
C103 VSS.t24 VSS 0.02426f
C104 VSS.t28 VSS 0.02462f
C105 VSS.t32 VSS 0.02462f
C106 VSS.t30 VSS 0.02426f
C107 VSS.t18 VSS 0.02426f
C108 VSS.t20 VSS 0.02462f
C109 VSS.t26 VSS 0.02462f
C110 VSS.t22 VSS 0.02426f
C111 VDD.n0 VSS 0.05875f
C112 VDD.n1 VSS 0.05737f
C113 EVEN_P.t0 VSS 0.15023f
C114 EVEN_P.n0 VSS 0.41039f
C115 EVEN_P.n1 VSS 0.99257f
C116 EVEN_P.n2 VSS 0.09742f
C117 EVEN_P.t2 VSS 0.3583f
C118 EVEN_P.n3 VSS 0.0998f
C119 EVEN_P.t1 VSS 0.3583f
C120 EVEN_P.n4 VSS 0.0998f
C121 EVEN_P.n5 VSS 0.08485f
C122 EVEN_P.n6 VSS 0.3117f
C123 EVEN_P.t3 VSS 0.35626f
C124 EVEN_P.t4 VSS 0.35616f
C125 EVEN_P.n7 VSS 0.23089f
C126 EVEN_P.n8 VSS 0.6972f
C127 EVEN_N.t2 VSS 0.14592f
C128 EVEN_N.t1 VSS 0.34598f
C129 EVEN_N.t0 VSS 0.34608f
C130 EVEN_N.n0 VSS 0.22427f
C131 EVEN_N.n1 VSS 0.28537f
C132 EVEN_N.n2 VSS 0.95252f
C133 EVEN_N.n3 VSS 0.06896f
C134 EVEN_N.t4 VSS 0.35111f
C135 EVEN_N.t3 VSS 0.35111f
C136 EVEN_N.n4 VSS 0.09694f
C137 EVEN_N.n5 VSS 0.09694f
C138 EVEN_N.n6 VSS 0.08241f
C139 EVEN_N.n7 VSS 0.30276f
C140 EVEN_N.n8 VSS 0.67721f
C141 ODD_P.t2 VSS 0.14308f
C142 ODD_P.n0 VSS 0.36466f
C143 ODD_P.n1 VSS 1.01479f
C144 ODD_P.n2 VSS 0.06763f
C145 ODD_P.t4 VSS 0.34421f
C146 ODD_P.n3 VSS 0.09505f
C147 ODD_P.t3 VSS 0.34421f
C148 ODD_P.n4 VSS 0.09505f
C149 ODD_P.n5 VSS 0.08081f
C150 ODD_P.n6 VSS 0.29688f
C151 ODD_P.t1 VSS 0.34166f
C152 ODD_P.t0 VSS 0.34157f
C153 ODD_P.n7 VSS 0.21991f
C154 ODD_P.n8 VSS 0.66405f
C155 ODD_N.t4 VSS 0.14707f
C156 ODD_N.t0 VSS 0.34833f
C157 ODD_N.t1 VSS 0.34843f
C158 ODD_N.n0 VSS 0.22604f
C159 ODD_N.n1 VSS 0.30504f
C160 ODD_N.n2 VSS 0.89821f
C161 ODD_N.n3 VSS 0.09537f
C162 ODD_N.t3 VSS 0.35085f
C163 ODD_N.t2 VSS 0.35085f
C164 ODD_N.n4 VSS 0.0977f
C165 ODD_N.n5 VSS 0.0977f
C166 ODD_N.n6 VSS 0.08306f
C167 ODD_N.n7 VSS 0.30514f
C168 ODD_N.n8 VSS 0.68254f
C169 DATA_N.n0 VSS 0.1615f
C170 DATA_N.n1 VSS 0.55796f
C171 DATA_N.n2 VSS 3.3336f
C172 DATA_P.n0 VSS 0.52809f
C173 DATA_P.n1 VSS 0.24315f
C174 DATA_P.n2 VSS 4.32051f
C175 CLK_P.n0 VSS 0.14858f
C176 CLK_P.n1 VSS 0.28554f
C177 CLK_P.n2 VSS 2.64355f
C178 CLK_N.n0 VSS 0.16186f
C179 CLK_N.n1 VSS 0.32896f
C180 CLK_N.n2 VSS 2.38196f
C181 VBIAS.n0 VSS 0.02173f
C182 VBIAS.n1 VSS 0.02331f
C183 VBIAS.n2 VSS 0.02331f
C184 VBIAS.n3 VSS 0.02173f
C185 VBIAS.n4 VSS 0.19166f
C186 VBIAS.n5 VSS 0.02173f
C187 VBIAS.n6 VSS 0.02331f
C188 VBIAS.n7 VSS 0.02331f
C189 VBIAS.n8 VSS 0.02173f
C190 VBIAS.n9 VSS 0.0661f
C191 VBIAS.n10 VSS 0.80826f
C192 VBIAS.n11 VSS 0.10366f
.ends
