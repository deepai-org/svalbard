* PEX produced using /foss/tools/sak/sak-pex.sh with m=3 and s=1 (extresist threshold=0 mOhm, minres=1 mOhm, mindelay=0 ps)
* NGSPICE file created from serdes_termination_pex.ext - technology: gf180mcuD

.subckt serdes_termination_pex RXP RXN TERM_EN0_N TERM_EN1_N TERM_EN2_N TERM_EN3_N
+ TERM_EN4_N TERM_EN5_N TERM_EN6_N VDD VSS
X0 a_n1920_n2400.t0 TERM_EN2_N.t3 VDD.t5 VDD.t4 pfet_03v3 ad=0.88p pd=4.88u as=0.88p ps=4.88u w=2u l=0.28u
X1 a_5204_n2200.t4 a_5280_n2400.t2 a_5300_n3100.t4 VSS.t35 nfet_03v3 ad=4.4p pd=20.88u as=2.6p ps=10.52u w=10u l=0.28u
X2 a_1680_n2400.t0 TERM_EN4_N.t3 VDD.t21 VDD.t20 pfet_03v3 ad=0.88p pd=4.88u as=0.88p ps=4.88u w=2u l=0.28u
X3 a_n100_n3100.t2 RXN.t4 VSS.t9 ppolyf_u r_width=1u r_length=1u
X4 a_n5500_n2957.t4 TERM_EN0_N.t1 a_n5596_n2200.t3 VDD.t18 pfet_03v3 ad=2.6p pd=10.52u as=4.4p ps=20.88u w=10u l=0.28u
X5 a_1604_n2200.t3 TERM_EN4_N.t0 a_1700_n3100.t2 VDD.t23 pfet_03v3 ad=4.4p pd=20.88u as=2.6p ps=10.52u w=10u l=0.28u
X6 a_3500_n3100.t4 a_3480_n2400.t3 a_3404_n2200.t4 VSS.t33 nfet_03v3 ad=2.6p pd=10.52u as=4.4p ps=20.88u w=10u l=0.28u
X7 a_3500_n3100.t0 RXN.t2 VSS.t3 ppolyf_u r_width=1u r_length=1u
X8 a_n1920_n2400.t1 TERM_EN2_N.t2 VSS.t11 VSS.t10 nfet_03v3 ad=0.44p pd=2.88u as=0.44p ps=2.88u w=1u l=0.28u
X9 a_n1900_n3100.t2 RXN.t5 VSS.t12 ppolyf_u r_width=1u r_length=1u
X10 a_1680_n2400.t1 TERM_EN4_N.t2 VSS.t29 VSS.t26 nfet_03v3 ad=0.44p pd=2.88u as=0.44p ps=2.88u w=1u l=0.28u
X11 RXP.t4 a_n3796_n2200.t0 VSS.t13 ppolyf_u r_width=1u r_length=2.43u
X12 a_n120_n2400.t0 TERM_EN3_N.t3 VDD.t1 VDD.t0 pfet_03v3 ad=0.88p pd=4.88u as=0.88p ps=4.88u w=2u l=0.28u
X13 a_3404_n2200.t2 TERM_EN5_N.t0 a_3500_n3100.t1 VDD.t15 pfet_03v3 ad=4.4p pd=20.88u as=2.6p ps=10.52u w=10u l=0.28u
X14 a_n100_n3100.t3 a_n120_n2400.t3 a_n196_n2200.t2 VSS.t15 nfet_03v3 ad=2.6p pd=10.52u as=4.4p ps=20.88u w=10u l=0.28u
X15 a_5300_n3100.t1 a_5280_n2400.t3 a_5204_n2200.t1 VSS.t24 nfet_03v3 ad=2.6p pd=10.52u as=4.4p ps=20.88u w=10u l=0.28u
X16 a_5300_n3100.t0 RXN.t1 VSS.t1 ppolyf_u r_width=1u r_length=1u
X17 a_n120_n2400.t1 TERM_EN3_N.t2 VSS.t6 VSS.t5 nfet_03v3 ad=0.44p pd=2.88u as=0.44p ps=2.88u w=1u l=0.28u
X18 RXP.t0 RXN.t0 VSS.t0 ppolyf_u r_width=4u r_length=1.23u
X19 RXP.t2 a_5204_n2200.t0 VSS.t8 ppolyf_u r_width=1u r_length=1u
X20 a_n100_n3100.t0 TERM_EN3_N.t1 a_n196_n2200.t0 VDD.t2 pfet_03v3 ad=2.6p pd=10.52u as=4.4p ps=20.88u w=10u l=0.28u
X21 a_5204_n2200.t3 TERM_EN6_N.t0 a_5300_n3100.t2 VDD.t27 pfet_03v3 ad=4.4p pd=20.88u as=2.6p ps=10.52u w=10u l=0.28u
X22 a_n3720_n2400.t0 TERM_EN1_N.t3 VDD.t9 VDD.t8 pfet_03v3 ad=0.88p pd=4.88u as=0.88p ps=4.88u w=2u l=0.28u
X23 a_3480_n2400.t0 TERM_EN5_N.t3 VDD.t13 VDD.t12 pfet_03v3 ad=0.88p pd=4.88u as=0.88p ps=4.88u w=2u l=0.28u
X24 a_n3720_n2400.t1 TERM_EN1_N.t2 VSS.t18 VSS.t13 nfet_03v3 ad=0.44p pd=2.88u as=0.44p ps=2.88u w=1u l=0.28u
X25 a_n1996_n2200.t1 TERM_EN2_N.t0 a_n1900_n3100.t1 VDD.t7 pfet_03v3 ad=4.4p pd=20.88u as=2.6p ps=10.52u w=10u l=0.28u
X26 a_3480_n2400.t1 TERM_EN5_N.t2 VSS.t19 VSS.t7 nfet_03v3 ad=0.44p pd=2.88u as=0.44p ps=2.88u w=1u l=0.28u
X27 RXP.t5 a_n5596_n2200.t0 VSS.t14 ppolyf_u r_width=1u r_length=2.43u
X28 RXP.t3 a_n1996_n2200.t2 VSS.t10 ppolyf_u r_width=1u r_length=1u
X29 a_n1900_n3100.t3 a_n1920_n2400.t3 a_n1996_n2200.t3 VSS.t16 nfet_03v3 ad=2.6p pd=10.52u as=4.4p ps=20.88u w=10u l=0.28u
X30 a_n3796_n2200.t2 TERM_EN1_N.t0 a_n3700_n2957.t2 VDD.t11 pfet_03v3 ad=4.4p pd=20.88u as=2.6p ps=10.52u w=10u l=0.28u
X31 RXP.t7 a_n196_n2200.t4 VSS.t5 ppolyf_u r_width=1u r_length=1u
X32 a_n5520_n2400.t0 TERM_EN0_N.t3 VDD.t17 VDD.t16 pfet_03v3 ad=0.88p pd=4.88u as=0.88p ps=4.88u w=2u l=0.28u
X33 a_n5596_n2200.t4 TERM_EN0_N.t0 a_n5500_n2957.t3 VDD.t19 pfet_03v3 ad=4.4p pd=20.88u as=2.6p ps=10.52u w=10u l=0.28u
X34 a_1700_n3100.t3 TERM_EN4_N.t1 a_1604_n2200.t2 VDD.t22 pfet_03v3 ad=2.6p pd=10.52u as=4.4p ps=20.88u w=10u l=0.28u
X35 a_n3700_n2957.t3 a_n3720_n2400.t3 a_n3796_n2200.t3 VSS.t20 nfet_03v3 ad=2.6p pd=10.52u as=4.4p ps=20.88u w=10u l=0.28u
X36 a_5280_n2400.t0 TERM_EN6_N.t3 VDD.t25 VDD.t24 pfet_03v3 ad=0.88p pd=4.88u as=0.88p ps=4.88u w=2u l=0.28u
X37 a_n5520_n2400.t1 TERM_EN0_N.t2 VSS.t28 VSS.t14 nfet_03v3 ad=0.44p pd=2.88u as=0.44p ps=2.88u w=1u l=0.28u
X38 RXP.t6 a_1604_n2200.t1 VSS.t26 ppolyf_u r_width=1u r_length=1u
X39 a_5280_n2400.t1 TERM_EN6_N.t2 VSS.t34 VSS.t8 nfet_03v3 ad=0.44p pd=2.88u as=0.44p ps=2.88u w=1u l=0.28u
X40 a_n196_n2200.t1 TERM_EN3_N.t0 a_n100_n3100.t1 VDD.t3 pfet_03v3 ad=4.4p pd=20.88u as=2.6p ps=10.52u w=10u l=0.28u
X41 a_n1996_n2200.t4 a_n1920_n2400.t2 a_n1900_n3100.t4 VSS.t31 nfet_03v3 ad=4.4p pd=20.88u as=2.6p ps=10.52u w=10u l=0.28u
X42 a_1604_n2200.t0 a_1680_n2400.t2 a_1700_n3100.t0 VSS.t2 nfet_03v3 ad=4.4p pd=20.88u as=2.6p ps=10.52u w=10u l=0.28u
X43 a_3500_n3100.t2 TERM_EN5_N.t1 a_3404_n2200.t1 VDD.t14 pfet_03v3 ad=2.6p pd=10.52u as=4.4p ps=20.88u w=10u l=0.28u
X44 a_n5500_n2957.t0 a_n5520_n2400.t3 a_n5596_n2200.t1 VSS.t21 nfet_03v3 ad=2.6p pd=10.52u as=4.4p ps=20.88u w=10u l=0.28u
X45 a_n3700_n2957.t0 RXN.t6 VSS.t17 ppolyf_u r_width=1u r_length=2.43u
X46 a_n1900_n3100.t0 TERM_EN2_N.t1 a_n1996_n2200.t0 VDD.t6 pfet_03v3 ad=2.6p pd=10.52u as=4.4p ps=20.88u w=10u l=0.28u
X47 a_5300_n3100.t3 TERM_EN6_N.t1 a_5204_n2200.t2 VDD.t26 pfet_03v3 ad=2.6p pd=10.52u as=4.4p ps=20.88u w=10u l=0.28u
X48 a_n3796_n2200.t4 a_n3720_n2400.t2 a_n3700_n2957.t4 VSS.t30 nfet_03v3 ad=4.4p pd=20.88u as=2.6p ps=10.52u w=10u l=0.28u
X49 a_3404_n2200.t3 a_3480_n2400.t2 a_3500_n3100.t3 VSS.t25 nfet_03v3 ad=4.4p pd=20.88u as=2.6p ps=10.52u w=10u l=0.28u
X50 a_n196_n2200.t3 a_n120_n2400.t2 a_n100_n3100.t4 VSS.t23 nfet_03v3 ad=4.4p pd=20.88u as=2.6p ps=10.52u w=10u l=0.28u
X51 a_n5500_n2957.t2 RXN.t7 VSS.t27 ppolyf_u r_width=1u r_length=2.43u
X52 a_1700_n3100.t1 RXN.t3 VSS.t4 ppolyf_u r_width=1u r_length=1u
X53 a_n3700_n2957.t1 TERM_EN1_N.t1 a_n3796_n2200.t1 VDD.t10 pfet_03v3 ad=2.6p pd=10.52u as=4.4p ps=20.88u w=10u l=0.28u
X54 a_1700_n3100.t4 a_1680_n2400.t3 a_1604_n2200.t4 VSS.t32 nfet_03v3 ad=2.6p pd=10.52u as=4.4p ps=20.88u w=10u l=0.28u
X55 RXP.t1 a_3404_n2200.t0 VSS.t7 ppolyf_u r_width=1u r_length=1u
X56 a_n5596_n2200.t2 a_n5520_n2400.t2 a_n5500_n2957.t1 VSS.t22 nfet_03v3 ad=4.4p pd=20.88u as=2.6p ps=10.52u w=10u l=0.28u
R0 RXN.n4 RXN.t7 16.444
R1 RXN.n5 RXN.t5 15.7187
R2 RXN.n3 RXN.t4 15.7187
R3 RXN.n2 RXN.t3 15.7187
R4 RXN.n1 RXN.t2 15.7187
R5 RXN.n0 RXN.t1 15.7187
R6 RXN.n4 RXN.t6 15.634
R7 RXN.n0 RXN.t0 13.2682
R8 RXN.n5 RXN.n4 0.8105
R9 RXN.n3 RXN.n2 0.8105
R10 RXN.n2 RXN.n1 0.8105
R11 RXN.n1 RXN.n0 0.8105
R12 RXN RXN.n5 0.6305
R13 RXN RXN.n3 0.1805
R14 RXP.n4 RXP.t5 16.444
R15 RXP.n0 RXP.t2 15.7187
R16 RXP.n1 RXP.t1 15.7187
R17 RXP.n2 RXP.t6 15.7187
R18 RXP.n3 RXP.t7 15.7187
R19 RXP.n5 RXP.t3 15.7187
R20 RXP.n4 RXP.t4 15.634
R21 RXP.n0 RXP.t0 13.2682
R22 RXP.n5 RXP.n4 0.8105
R23 RXP.n3 RXP.n2 0.8105
R24 RXP.n2 RXP.n1 0.8105
R25 RXP.n1 RXP.n0 0.8105
R26 RXP RXP.n5 0.6305
R27 RXP RXP.n3 0.1805
R28 TERM_EN6_N.n0 TERM_EN6_N.t0 139.688
R29 TERM_EN6_N.n0 TERM_EN6_N.t1 139.688
R30 TERM_EN6_N.n2 TERM_EN6_N.t3 62.9541
R31 TERM_EN6_N.n1 TERM_EN6_N.t2 49.9184
R32 TERM_EN6_N.n1 TERM_EN6_N.n0 22.4
R33 TERM_EN6_N.n2 TERM_EN6_N.n1 0.7835
R34 TERM_EN6_N TERM_EN6_N.n2 0.382357
R35 TERM_EN5_N.n0 TERM_EN5_N.t0 139.688
R36 TERM_EN5_N.n0 TERM_EN5_N.t1 139.688
R37 TERM_EN5_N.n2 TERM_EN5_N.t3 62.9541
R38 TERM_EN5_N.n1 TERM_EN5_N.t2 49.9184
R39 TERM_EN5_N.n1 TERM_EN5_N.n0 22.4
R40 TERM_EN5_N.n2 TERM_EN5_N.n1 0.7835
R41 TERM_EN5_N TERM_EN5_N.n2 0.382357
R42 TERM_EN4_N.n0 TERM_EN4_N.t0 139.688
R43 TERM_EN4_N.n0 TERM_EN4_N.t1 139.688
R44 TERM_EN4_N.n2 TERM_EN4_N.t3 62.9541
R45 TERM_EN4_N.n1 TERM_EN4_N.t2 49.9184
R46 TERM_EN4_N.n1 TERM_EN4_N.n0 22.4
R47 TERM_EN4_N.n2 TERM_EN4_N.n1 0.7835
R48 TERM_EN4_N TERM_EN4_N.n2 0.382357
R49 TERM_EN3_N.n0 TERM_EN3_N.t0 139.688
R50 TERM_EN3_N.n0 TERM_EN3_N.t1 139.688
R51 TERM_EN3_N.n2 TERM_EN3_N.t3 62.9541
R52 TERM_EN3_N.n1 TERM_EN3_N.t2 49.9184
R53 TERM_EN3_N.n1 TERM_EN3_N.n0 22.4
R54 TERM_EN3_N.n2 TERM_EN3_N.n1 0.7835
R55 TERM_EN3_N TERM_EN3_N.n2 0.382357
R56 TERM_EN2_N.n0 TERM_EN2_N.t0 139.688
R57 TERM_EN2_N.n0 TERM_EN2_N.t1 139.688
R58 TERM_EN2_N.n2 TERM_EN2_N.t3 62.9541
R59 TERM_EN2_N.n1 TERM_EN2_N.t2 49.9184
R60 TERM_EN2_N.n1 TERM_EN2_N.n0 22.4
R61 TERM_EN2_N.n2 TERM_EN2_N.n1 0.7835
R62 TERM_EN2_N TERM_EN2_N.n2 0.382357
R63 TERM_EN1_N.n0 TERM_EN1_N.t0 139.688
R64 TERM_EN1_N.n0 TERM_EN1_N.t1 139.688
R65 TERM_EN1_N.n2 TERM_EN1_N.t3 62.9541
R66 TERM_EN1_N.n1 TERM_EN1_N.t2 49.9184
R67 TERM_EN1_N.n1 TERM_EN1_N.n0 22.4
R68 TERM_EN1_N.n2 TERM_EN1_N.n1 0.7835
R69 TERM_EN1_N TERM_EN1_N.n2 0.382357
R70 TERM_EN0_N.n0 TERM_EN0_N.t0 139.688
R71 TERM_EN0_N.n0 TERM_EN0_N.t1 139.688
R72 TERM_EN0_N.n2 TERM_EN0_N.t3 62.9541
R73 TERM_EN0_N.n1 TERM_EN0_N.t2 49.9184
R74 TERM_EN0_N.n1 TERM_EN0_N.n0 22.4
R75 TERM_EN0_N.n2 TERM_EN0_N.n1 0.7835
R76 TERM_EN0_N TERM_EN0_N.n2 0.382357
R77 VDD.n5 VDD.t16 923.077
R78 VDD.n6 VDD.t8 923.077
R79 VDD.n10 VDD.t4 923.077
R80 VDD.n11 VDD.t0 923.077
R81 VDD.n15 VDD.t20 923.077
R82 VDD.n16 VDD.t12 923.077
R83 VDD.t10 VDD.t19 640.625
R84 VDD.t6 VDD.t11 640.625
R85 VDD.t2 VDD.t7 640.625
R86 VDD.t22 VDD.t3 640.625
R87 VDD.t14 VDD.t23 640.625
R88 VDD.t26 VDD.t15 640.625
R89 VDD.n3 VDD.t16 483.238
R90 VDD.t8 VDD.n5 461.538
R91 VDD.n6 VDD.t4 461.538
R92 VDD.t0 VDD.n10 461.538
R93 VDD.n11 VDD.t20 461.538
R94 VDD.t12 VDD.n15 461.538
R95 VDD.n16 VDD.t24 461.538
R96 VDD.n19 VDD.t27 313.94
R97 VDD.t19 VDD.t18 62.5005
R98 VDD.t11 VDD.t10 62.5005
R99 VDD.t7 VDD.t6 62.5005
R100 VDD.t3 VDD.t2 62.5005
R101 VDD.t23 VDD.t22 62.5005
R102 VDD.t15 VDD.t14 62.5005
R103 VDD.t27 VDD.t26 62.5005
R104 VDD.n5 VDD.n4 21.6005
R105 VDD.n7 VDD.n6 21.6005
R106 VDD.n10 VDD.n9 21.6005
R107 VDD.n12 VDD.n11 21.6005
R108 VDD.n15 VDD.n14 21.6005
R109 VDD.n17 VDD.n16 21.6005
R110 VDD.n18 VDD.t25 11.724
R111 VDD.n0 VDD.t13 11.724
R112 VDD.n13 VDD.t21 11.724
R113 VDD.n1 VDD.t1 11.724
R114 VDD.n8 VDD.t5 11.724
R115 VDD.n2 VDD.t9 11.724
R116 VDD.n3 VDD.t17 11.724
R117 VDD.n19 VDD.n18 10.4005
R118 VDD VDD.n19 1.64494
R119 VDD.n4 VDD.n3 0.8005
R120 VDD.n7 VDD.n2 0.8005
R121 VDD.n9 VDD.n8 0.8005
R122 VDD.n12 VDD.n1 0.8005
R123 VDD.n14 VDD.n13 0.8005
R124 VDD.n17 VDD.n0 0.8005
R125 VDD.n4 VDD.n2 0.1005
R126 VDD.n8 VDD.n7 0.1005
R127 VDD.n9 VDD.n1 0.1005
R128 VDD.n13 VDD.n12 0.1005
R129 VDD.n14 VDD.n0 0.1005
R130 VDD.n18 VDD.n17 0.1005
R131 VSS.n148 VSS.n12 9750
R132 VSS.n132 VSS.n131 7962.5
R133 VSS.n132 VSS.n130 7800
R134 VSS.n130 VSS.n129 7800
R135 VSS.n129 VSS.n22 7800
R136 VSS.n123 VSS.n22 7800
R137 VSS.n123 VSS.n122 7800
R138 VSS.n122 VSS.n121 7800
R139 VSS.n121 VSS.n26 7800
R140 VSS.n115 VSS.n26 7800
R141 VSS.n115 VSS.n114 7800
R142 VSS.n114 VSS.n113 7800
R143 VSS.n149 VSS.n148 6552
R144 VSS.n131 VSS.n18 6500
R145 VSS.n18 VSS.n12 4550
R146 VSS.n113 VSS.n30 4044.44
R147 VSS.n92 VSS.n34 1950
R148 VSS.n107 VSS.n106 1649.9
R149 VSS.n108 VSS.n107 1305.2
R150 VSS.n92 VSS.n91 1300
R151 VSS.n103 VSS.n102 1221.3
R152 VSS.n104 VSS.n103 1221.3
R153 VSS.n105 VSS.n104 1221.3
R154 VSS.n106 VSS.n105 1221.3
R155 VSS.n102 VSS.n101 1220.9
R156 VSS.n101 VSS.n17 1220.49
R157 VSS.n107 VSS.n34 910
R158 VSS.n138 VSS.n17 818.093
R159 VSS.t0 VSS.n90 780
R160 VSS.n107 VSS.n100 680.234
R161 VSS.n66 VSS.n65 613.601
R162 VSS.n68 VSS.n67 613.601
R163 VSS.n71 VSS.n58 613.601
R164 VSS.n77 VSS.n54 613.601
R165 VSS.n84 VSS.n80 613.601
R166 VSS.n83 VSS.n82 613.601
R167 VSS.n91 VSS.n38 468
R168 VSS.n107 VSS.n30 361.111
R169 VSS.n149 VSS.n10 338
R170 VSS.n59 VSS.n10 223.601
R171 VSS.n65 VSS.n60 223.601
R172 VSS.n69 VSS.n68 223.601
R173 VSS.n71 VSS.n70 223.601
R174 VSS.n78 VSS.n77 223.601
R175 VSS.n80 VSS.n79 223.601
R176 VSS.n82 VSS.n81 223.601
R177 VSS.n90 VSS.n40 223.601
R178 VSS.n91 VSS.t0 130
R179 VSS.n17 VSS.t14 120.025
R180 VSS.n101 VSS.t13 120.025
R181 VSS.n102 VSS.t10 119.822
R182 VSS.n103 VSS.t5 119.822
R183 VSS.n104 VSS.t26 119.822
R184 VSS.n105 VSS.t7 119.822
R185 VSS.n106 VSS.t8 119.822
R186 VSS.n59 VSS.t21 114.4
R187 VSS.n60 VSS.t22 114.4
R188 VSS.n66 VSS.t20 114.4
R189 VSS.n67 VSS.t30 114.4
R190 VSS.n69 VSS.t16 114.4
R191 VSS.n70 VSS.t31 114.4
R192 VSS.n58 VSS.t15 114.4
R193 VSS.t23 VSS.n54 114.4
R194 VSS.n78 VSS.t32 114.4
R195 VSS.n79 VSS.t2 114.4
R196 VSS.t33 VSS.n84 114.4
R197 VSS.n83 VSS.t25 114.4
R198 VSS.n81 VSS.t24 114.4
R199 VSS.t35 VSS.n40 114.4
R200 VSS.n108 VSS.n31 77.0005
R201 VSS.n138 VSS.n18 75.5819
R202 VSS.n49 VSS.n39 68.2505
R203 VSS.n133 VSS.n19 59.5005
R204 VSS.n143 VSS.n9 52.5005
R205 VSS.n147 VSS.n14 52.5005
R206 VSS.n147 VSS.n13 52.5005
R207 VSS.n140 VSS.n13 52.5005
R208 VSS.n137 VSS.n16 52.5005
R209 VSS.n137 VSS.n19 52.5005
R210 VSS.n64 VSS.n8 52.5005
R211 VSS.n64 VSS.n61 52.5005
R212 VSS.n61 VSS.n57 52.5005
R213 VSS.n72 VSS.n57 52.5005
R214 VSS.n72 VSS.n55 52.5005
R215 VSS.n76 VSS.n55 52.5005
R216 VSS.n76 VSS.n53 52.5005
R217 VSS.n85 VSS.n53 52.5005
R218 VSS.n85 VSS.n41 52.5005
R219 VSS.n89 VSS.n41 52.5005
R220 VSS.n89 VSS.n39 52.5005
R221 VSS.n47 VSS.n46 52.5005
R222 VSS.n93 VSS.n37 52.5005
R223 VSS.n94 VSS.n93 52.5005
R224 VSS.n94 VSS.n35 52.5005
R225 VSS.n98 VSS.n35 52.5005
R226 VSS.n108 VSS.n33 52.5005
R227 VSS.n133 VSS.n21 52.5005
R228 VSS.n128 VSS.n21 52.5005
R229 VSS.n128 VSS.n23 52.5005
R230 VSS.n124 VSS.n23 52.5005
R231 VSS.n124 VSS.n25 52.5005
R232 VSS.n120 VSS.n25 52.5005
R233 VSS.n120 VSS.n27 52.5005
R234 VSS.n116 VSS.n27 52.5005
R235 VSS.n116 VSS.n29 52.5005
R236 VSS.n112 VSS.n29 52.5005
R237 VSS.n112 VSS.n31 52.5005
R238 VSS.t21 VSS.t27 52.0005
R239 VSS.t27 VSS.t22 52.0005
R240 VSS.t17 VSS.t20 52.0005
R241 VSS.t17 VSS.t30 52.0005
R242 VSS.t16 VSS.t12 52.0005
R243 VSS.t12 VSS.t31 52.0005
R244 VSS.t15 VSS.t9 52.0005
R245 VSS.t9 VSS.t23 52.0005
R246 VSS.t32 VSS.t4 52.0005
R247 VSS.t4 VSS.t2 52.0005
R248 VSS.t3 VSS.t33 52.0005
R249 VSS.t3 VSS.t25 52.0005
R250 VSS.t24 VSS.t1 52.0005
R251 VSS.t1 VSS.t35 52.0005
R252 VSS.n151 VSS.n8 50.7505
R253 VSS VSS.n153 16.7669
R254 VSS.n0 VSS.t34 15.202
R255 VSS.n5 VSS.t28 14.302
R256 VSS.n4 VSS.t18 14.302
R257 VSS.n3 VSS.t11 14.302
R258 VSS.n2 VSS.t6 14.302
R259 VSS.n1 VSS.t29 14.302
R260 VSS.n0 VSS.t19 14.302
R261 VSS VSS.n5 10.3561
R262 VSS.t0 VSS.n39 5.2005
R263 VSS.n51 VSS.n39 5.2005
R264 VSS.n90 VSS.n89 5.2005
R265 VSS.n89 VSS.n88 5.2005
R266 VSS.n82 VSS.n41 5.2005
R267 VSS.n87 VSS.n41 5.2005
R268 VSS.n85 VSS.t3 5.2005
R269 VSS.n86 VSS.n85 5.2005
R270 VSS.n80 VSS.n53 5.2005
R271 VSS.n53 VSS.n52 5.2005
R272 VSS.n77 VSS.n76 5.2005
R273 VSS.n76 VSS.n75 5.2005
R274 VSS.t9 VSS.n55 5.2005
R275 VSS.n74 VSS.n55 5.2005
R276 VSS.n72 VSS.n71 5.2005
R277 VSS.n73 VSS.n72 5.2005
R278 VSS.n68 VSS.n57 5.2005
R279 VSS.n57 VSS.n56 5.2005
R280 VSS.n61 VSS.t17 5.2005
R281 VSS.n62 VSS.n61 5.2005
R282 VSS.n65 VSS.n64 5.2005
R283 VSS.n64 VSS.n63 5.2005
R284 VSS.n10 VSS.n8 5.2005
R285 VSS.n8 VSS.n6 5.2005
R286 VSS.n50 VSS.n49 5.2005
R287 VSS.n47 VSS.n42 5.2005
R288 VSS.n46 VSS.n44 5.2005
R289 VSS.n43 VSS.n37 5.2005
R290 VSS.n93 VSS.n92 5.2005
R291 VSS.n93 VSS.n36 5.2005
R292 VSS.n94 VSS.n34 5.2005
R293 VSS.n95 VSS.n94 5.2005
R294 VSS.n100 VSS.n35 5.2005
R295 VSS.n96 VSS.n35 5.2005
R296 VSS.n98 VSS.n97 5.2005
R297 VSS.n33 VSS.n32 5.2005
R298 VSS.n109 VSS.n108 5.2005
R299 VSS.n133 VSS.n132 5.2005
R300 VSS.n134 VSS.n133 5.2005
R301 VSS.n130 VSS.n21 5.2005
R302 VSS.n21 VSS.n20 5.2005
R303 VSS.n129 VSS.n128 5.2005
R304 VSS.n128 VSS.n127 5.2005
R305 VSS.n23 VSS.n22 5.2005
R306 VSS.n126 VSS.n23 5.2005
R307 VSS.n124 VSS.n123 5.2005
R308 VSS.n125 VSS.n124 5.2005
R309 VSS.n122 VSS.n25 5.2005
R310 VSS.n25 VSS.n24 5.2005
R311 VSS.n121 VSS.n120 5.2005
R312 VSS.n120 VSS.n119 5.2005
R313 VSS.n27 VSS.n26 5.2005
R314 VSS.n118 VSS.n27 5.2005
R315 VSS.n116 VSS.n115 5.2005
R316 VSS.n117 VSS.n116 5.2005
R317 VSS.n114 VSS.n29 5.2005
R318 VSS.n29 VSS.n28 5.2005
R319 VSS.n113 VSS.n112 5.2005
R320 VSS.n112 VSS.n111 5.2005
R321 VSS.n31 VSS.n30 5.2005
R322 VSS.n110 VSS.n31 5.2005
R323 VSS.n131 VSS.n19 5.2005
R324 VSS.n135 VSS.n19 5.2005
R325 VSS.n138 VSS.n137 5.2005
R326 VSS.n137 VSS.n136 5.2005
R327 VSS.n16 VSS.n15 5.2005
R328 VSS.n141 VSS.n140 5.2005
R329 VSS.n13 VSS.n12 5.2005
R330 VSS.n142 VSS.n13 5.2005
R331 VSS.n148 VSS.n147 5.2005
R332 VSS.n147 VSS.n146 5.2005
R333 VSS.n145 VSS.n14 5.2005
R334 VSS.n144 VSS.n143 5.2005
R335 VSS.n9 VSS.n7 5.2005
R336 VSS.n152 VSS.n151 5.2005
R337 VSS.n81 VSS.n40 4.48215
R338 VSS.n84 VSS.n83 4.48215
R339 VSS.n79 VSS.n78 4.48215
R340 VSS.n58 VSS.n54 4.48215
R341 VSS.n70 VSS.n69 4.48215
R342 VSS.n48 VSS.n47 4.34122
R343 VSS.n46 VSS.n45 4.34122
R344 VSS.n99 VSS.n98 4.34122
R345 VSS.n139 VSS.n16 4.34122
R346 VSS.n143 VSS.n11 4.34122
R347 VSS.n151 VSS.n150 4.34122
R348 VSS.n150 VSS.n9 4.34122
R349 VSS.n14 VSS.n11 4.34122
R350 VSS.n140 VSS.n139 4.34122
R351 VSS.n49 VSS.n48 4.34122
R352 VSS.n45 VSS.n37 4.34122
R353 VSS.n99 VSS.n33 4.34122
R354 VSS.n67 VSS.n66 3.6553
R355 VSS.n60 VSS.n59 3.6553
R356 VSS.n110 VSS.n109 0.9905
R357 VSS.n5 VSS.n4 0.9005
R358 VSS.n4 VSS.n3 0.9005
R359 VSS.n3 VSS.n2 0.9005
R360 VSS.n2 VSS.n1 0.9005
R361 VSS.n1 VSS.n0 0.9005
R362 VSS.n51 VSS.n50 0.878
R363 VSS.n135 VSS.n134 0.7655
R364 VSS.n63 VSS.n6 0.6755
R365 VSS.n63 VSS.n62 0.6755
R366 VSS.n62 VSS.n56 0.6755
R367 VSS.n73 VSS.n56 0.6755
R368 VSS.n74 VSS.n73 0.6755
R369 VSS.n75 VSS.n74 0.6755
R370 VSS.n75 VSS.n52 0.6755
R371 VSS.n86 VSS.n52 0.6755
R372 VSS.n87 VSS.n86 0.6755
R373 VSS.n88 VSS.n87 0.6755
R374 VSS.n88 VSS.n51 0.6755
R375 VSS.n50 VSS.n42 0.6755
R376 VSS.n44 VSS.n42 0.6755
R377 VSS.n44 VSS.n43 0.6755
R378 VSS.n43 VSS.n36 0.6755
R379 VSS.n95 VSS.n36 0.6755
R380 VSS.n96 VSS.n95 0.6755
R381 VSS.n97 VSS.n96 0.6755
R382 VSS.n97 VSS.n32 0.6755
R383 VSS.n109 VSS.n32 0.6755
R384 VSS.n134 VSS.n20 0.6755
R385 VSS.n127 VSS.n20 0.6755
R386 VSS.n127 VSS.n126 0.6755
R387 VSS.n126 VSS.n125 0.6755
R388 VSS.n125 VSS.n24 0.6755
R389 VSS.n119 VSS.n24 0.6755
R390 VSS.n119 VSS.n118 0.6755
R391 VSS.n118 VSS.n117 0.6755
R392 VSS.n117 VSS.n28 0.6755
R393 VSS.n111 VSS.n28 0.6755
R394 VSS.n111 VSS.n110 0.6755
R395 VSS.n152 VSS.n7 0.6755
R396 VSS.n144 VSS.n7 0.6755
R397 VSS.n145 VSS.n144 0.6755
R398 VSS.n146 VSS.n145 0.6755
R399 VSS.n146 VSS.n142 0.6755
R400 VSS.n142 VSS.n141 0.6755
R401 VSS.n141 VSS.n15 0.6755
R402 VSS.n136 VSS.n15 0.6755
R403 VSS.n136 VSS.n135 0.6755
R404 VSS.n153 VSS.n152 0.451459
R405 VSS.n48 VSS.n38 0.430889
R406 VSS.n45 VSS.n38 0.430889
R407 VSS.n100 VSS.n99 0.430889
R408 VSS.n139 VSS.n138 0.430889
R409 VSS.n149 VSS.n11 0.430889
R410 VSS.n150 VSS.n149 0.430889
R411 VSS.n153 VSS.n6 0.199597
R412 a_5300_n3100.n1 a_5300_n3100.t0 16.0556
R413 a_5300_n3100.n1 a_5300_n3100.n0 12.2615
R414 a_5300_n3100.n2 a_5300_n3100.n1 10.9828
R415 a_5300_n3100.n0 a_5300_n3100.t2 0.1825
R416 a_5300_n3100.n0 a_5300_n3100.t3 0.1825
R417 a_5300_n3100.n2 a_5300_n3100.t4 0.1643
R418 a_5300_n3100.t1 a_5300_n3100.n2 0.1643
R419 a_3500_n3100.n1 a_3500_n3100.t0 16.0556
R420 a_3500_n3100.n2 a_3500_n3100.n1 12.2615
R421 a_3500_n3100.n1 a_3500_n3100.n0 10.9828
R422 a_3500_n3100.t1 a_3500_n3100.n2 0.1825
R423 a_3500_n3100.n2 a_3500_n3100.t2 0.1825
R424 a_3500_n3100.n0 a_3500_n3100.t3 0.1643
R425 a_3500_n3100.n0 a_3500_n3100.t4 0.1643
R426 a_1700_n3100.n1 a_1700_n3100.t1 16.0556
R427 a_1700_n3100.n1 a_1700_n3100.n0 12.2615
R428 a_1700_n3100.n2 a_1700_n3100.n1 10.9828
R429 a_1700_n3100.n0 a_1700_n3100.t2 0.1825
R430 a_1700_n3100.n0 a_1700_n3100.t3 0.1825
R431 a_1700_n3100.t0 a_1700_n3100.n2 0.1643
R432 a_1700_n3100.n2 a_1700_n3100.t4 0.1643
R433 a_n100_n3100.n1 a_n100_n3100.t2 16.0556
R434 a_n100_n3100.n2 a_n100_n3100.n1 12.2615
R435 a_n100_n3100.n1 a_n100_n3100.n0 10.9828
R436 a_n100_n3100.n2 a_n100_n3100.t1 0.1825
R437 a_n100_n3100.t0 a_n100_n3100.n2 0.1825
R438 a_n100_n3100.n0 a_n100_n3100.t4 0.1643
R439 a_n100_n3100.n0 a_n100_n3100.t3 0.1643
R440 a_n1900_n3100.n1 a_n1900_n3100.t2 16.0556
R441 a_n1900_n3100.n2 a_n1900_n3100.n1 12.2615
R442 a_n1900_n3100.n1 a_n1900_n3100.n0 10.9828
R443 a_n1900_n3100.n2 a_n1900_n3100.t1 0.1825
R444 a_n1900_n3100.t0 a_n1900_n3100.n2 0.1825
R445 a_n1900_n3100.n0 a_n1900_n3100.t4 0.1643
R446 a_n1900_n3100.n0 a_n1900_n3100.t3 0.1643
R447 a_n3700_n2957.n1 a_n3700_n2957.t0 16.0389
R448 a_n3700_n2957.n2 a_n3700_n2957.n1 12.2615
R449 a_n3700_n2957.n1 a_n3700_n2957.n0 10.9828
R450 a_n3700_n2957.n2 a_n3700_n2957.t2 0.1825
R451 a_n3700_n2957.t1 a_n3700_n2957.n2 0.1825
R452 a_n3700_n2957.n0 a_n3700_n2957.t4 0.1643
R453 a_n3700_n2957.n0 a_n3700_n2957.t3 0.1643
R454 a_n5500_n2957.n1 a_n5500_n2957.t2 16.0389
R455 a_n5500_n2957.n1 a_n5500_n2957.n0 12.2615
R456 a_n5500_n2957.n2 a_n5500_n2957.n1 10.9828
R457 a_n5500_n2957.n0 a_n5500_n2957.t3 0.1825
R458 a_n5500_n2957.n0 a_n5500_n2957.t4 0.1825
R459 a_n5500_n2957.n2 a_n5500_n2957.t1 0.1643
R460 a_n5500_n2957.t0 a_n5500_n2957.n2 0.1643
R461 a_5204_n2200.n1 a_5204_n2200.t0 16.0556
R462 a_5204_n2200.n0 a_5204_n2200.t4 6.66284
R463 a_5204_n2200.t3 a_5204_n2200.n2 6.62866
R464 a_5204_n2200.n0 a_5204_n2200.t1 6.45713
R465 a_5204_n2200.n2 a_5204_n2200.t2 6.42295
R466 a_5204_n2200.n1 a_5204_n2200.n0 5.92629
R467 a_5204_n2200.n2 a_5204_n2200.n1 4.59524
R468 a_3404_n2200.n1 a_3404_n2200.t0 16.0556
R469 a_3404_n2200.n0 a_3404_n2200.t3 6.66284
R470 a_3404_n2200.t2 a_3404_n2200.n2 6.62866
R471 a_3404_n2200.n0 a_3404_n2200.t4 6.45713
R472 a_3404_n2200.n2 a_3404_n2200.t1 6.42295
R473 a_3404_n2200.n1 a_3404_n2200.n0 5.92629
R474 a_3404_n2200.n2 a_3404_n2200.n1 4.59524
R475 a_1604_n2200.n1 a_1604_n2200.t1 16.0556
R476 a_1604_n2200.n0 a_1604_n2200.t0 6.66284
R477 a_1604_n2200.t3 a_1604_n2200.n2 6.62866
R478 a_1604_n2200.n0 a_1604_n2200.t4 6.45713
R479 a_1604_n2200.n2 a_1604_n2200.t2 6.42295
R480 a_1604_n2200.n1 a_1604_n2200.n0 5.92629
R481 a_1604_n2200.n2 a_1604_n2200.n1 4.59524
R482 a_n196_n2200.n1 a_n196_n2200.t4 16.0556
R483 a_n196_n2200.n0 a_n196_n2200.t3 6.66284
R484 a_n196_n2200.t1 a_n196_n2200.n2 6.62866
R485 a_n196_n2200.n0 a_n196_n2200.t2 6.45713
R486 a_n196_n2200.n2 a_n196_n2200.t0 6.42295
R487 a_n196_n2200.n1 a_n196_n2200.n0 5.92629
R488 a_n196_n2200.n2 a_n196_n2200.n1 4.59524
R489 a_n1996_n2200.n1 a_n1996_n2200.t2 16.0556
R490 a_n1996_n2200.n0 a_n1996_n2200.t4 6.66284
R491 a_n1996_n2200.t1 a_n1996_n2200.n2 6.62866
R492 a_n1996_n2200.n0 a_n1996_n2200.t3 6.45713
R493 a_n1996_n2200.n2 a_n1996_n2200.t0 6.42295
R494 a_n1996_n2200.n1 a_n1996_n2200.n0 5.92629
R495 a_n1996_n2200.n2 a_n1996_n2200.n1 4.59524
R496 a_n3796_n2200.n1 a_n3796_n2200.t0 16.0389
R497 a_n3796_n2200.n0 a_n3796_n2200.t4 6.66284
R498 a_n3796_n2200.t2 a_n3796_n2200.n2 6.62866
R499 a_n3796_n2200.n0 a_n3796_n2200.t3 6.45713
R500 a_n3796_n2200.n2 a_n3796_n2200.t1 6.42295
R501 a_n3796_n2200.n1 a_n3796_n2200.n0 5.92629
R502 a_n3796_n2200.n2 a_n3796_n2200.n1 4.59524
R503 a_n5596_n2200.n1 a_n5596_n2200.t0 16.0389
R504 a_n5596_n2200.n0 a_n5596_n2200.t2 6.66284
R505 a_n5596_n2200.n2 a_n5596_n2200.t4 6.62866
R506 a_n5596_n2200.n0 a_n5596_n2200.t1 6.45713
R507 a_n5596_n2200.t3 a_n5596_n2200.n2 6.42295
R508 a_n5596_n2200.n1 a_n5596_n2200.n0 5.92629
R509 a_n5596_n2200.n2 a_n5596_n2200.n1 4.59524
R510 a_5280_n2400.n0 a_5280_n2400.t3 139.69
R511 a_5280_n2400.n0 a_5280_n2400.t2 139.69
R512 a_5280_n2400.n1 a_5280_n2400.n0 36.7175
R513 a_5280_n2400.n1 a_5280_n2400.t1 14.2148
R514 a_5280_n2400.t0 a_5280_n2400.n1 11.6368
R515 a_3480_n2400.n0 a_3480_n2400.t3 139.69
R516 a_3480_n2400.n0 a_3480_n2400.t2 139.69
R517 a_3480_n2400.n1 a_3480_n2400.n0 36.7175
R518 a_3480_n2400.n1 a_3480_n2400.t1 14.2148
R519 a_3480_n2400.t0 a_3480_n2400.n1 11.6368
R520 a_1680_n2400.n0 a_1680_n2400.t3 139.69
R521 a_1680_n2400.n0 a_1680_n2400.t2 139.69
R522 a_1680_n2400.n1 a_1680_n2400.n0 36.7175
R523 a_1680_n2400.n1 a_1680_n2400.t1 14.2148
R524 a_1680_n2400.t0 a_1680_n2400.n1 11.6368
R525 a_n120_n2400.n0 a_n120_n2400.t3 139.69
R526 a_n120_n2400.n0 a_n120_n2400.t2 139.69
R527 a_n120_n2400.n1 a_n120_n2400.n0 36.7175
R528 a_n120_n2400.n1 a_n120_n2400.t1 14.2148
R529 a_n120_n2400.t0 a_n120_n2400.n1 11.6368
R530 a_n1920_n2400.n0 a_n1920_n2400.t3 139.69
R531 a_n1920_n2400.n0 a_n1920_n2400.t2 139.69
R532 a_n1920_n2400.n1 a_n1920_n2400.n0 36.7175
R533 a_n1920_n2400.n1 a_n1920_n2400.t1 14.2148
R534 a_n1920_n2400.t0 a_n1920_n2400.n1 11.6368
R535 a_n3720_n2400.n0 a_n3720_n2400.t3 139.69
R536 a_n3720_n2400.n0 a_n3720_n2400.t2 139.69
R537 a_n3720_n2400.n1 a_n3720_n2400.n0 36.7175
R538 a_n3720_n2400.n1 a_n3720_n2400.t1 14.2148
R539 a_n3720_n2400.t0 a_n3720_n2400.n1 11.6368
R540 a_n5520_n2400.n0 a_n5520_n2400.t3 139.69
R541 a_n5520_n2400.n0 a_n5520_n2400.t2 139.69
R542 a_n5520_n2400.n1 a_n5520_n2400.n0 36.7175
R543 a_n5520_n2400.n1 a_n5520_n2400.t1 14.2148
R544 a_n5520_n2400.t0 a_n5520_n2400.n1 11.6368
C0 TERM_EN1_N RXP 0.30512f
C1 TERM_EN3_N RXP 0.32237f
C2 TERM_EN3_N TERM_EN4_N 0.0465f
C3 TERM_EN6_N TERM_EN5_N 0.0465f
C4 VDD TERM_EN0_N 1.78007f
C5 VDD TERM_EN2_N 1.83575f
C6 RXN RXP 0.18321f
C7 RXP TERM_EN5_N 0.32237f
C8 TERM_EN5_N TERM_EN4_N 0.0465f
C9 VDD TERM_EN6_N 1.77519f
C10 VDD RXP 0.49396f
C11 VDD TERM_EN4_N 1.83575f
C12 TERM_EN0_N RXP 0.29388f
C13 TERM_EN2_N RXP 0.32237f
C14 RXP TERM_EN6_N 0.32887f
C15 RXP TERM_EN4_N 0.32237f
C16 VDD TERM_EN1_N 1.83575f
C17 VDD TERM_EN3_N 1.83575f
C18 TERM_EN1_N TERM_EN0_N 0.0465f
C19 TERM_EN1_N TERM_EN2_N 0.0465f
C20 TERM_EN2_N TERM_EN3_N 0.0465f
C21 VDD TERM_EN5_N 1.83575f
C22 RXN VSS 11.28771f
C23 RXP VSS 11.08173f
C24 TERM_EN6_N VSS 2.70179f
C25 TERM_EN5_N VSS 2.57258f
C26 TERM_EN4_N VSS 2.57258f
C27 TERM_EN3_N VSS 2.57258f
C28 TERM_EN2_N VSS 2.5728f
C29 TERM_EN1_N VSS 2.58763f
C30 TERM_EN0_N VSS 2.80506f
C31 VDD VSS 0.1622p
C32 a_n5520_n2400.n0 VSS 0.79528f
C33 a_n5520_n2400.t1 VSS 0.12428f
C34 a_n5520_n2400.n1 VSS 1.89873f
C35 a_n5520_n2400.t0 VSS 0.17404f
C36 a_n3720_n2400.n0 VSS 0.82356f
C37 a_n3720_n2400.t1 VSS 0.12937f
C38 a_n3720_n2400.n1 VSS 1.96626f
C39 a_n3720_n2400.t0 VSS 0.18095f
C40 a_n1920_n2400.n0 VSS 0.82495f
C41 a_n1920_n2400.t1 VSS 0.12994f
C42 a_n1920_n2400.n1 VSS 1.96957f
C43 a_n1920_n2400.t0 VSS 0.18163f
C44 a_n120_n2400.n0 VSS 0.82495f
C45 a_n120_n2400.t1 VSS 0.12994f
C46 a_n120_n2400.n1 VSS 1.96957f
C47 a_n120_n2400.t0 VSS 0.18163f
C48 a_1680_n2400.n0 VSS 0.82495f
C49 a_1680_n2400.t1 VSS 0.12994f
C50 a_1680_n2400.n1 VSS 1.96957f
C51 a_1680_n2400.t0 VSS 0.18163f
C52 a_3480_n2400.n0 VSS 0.82495f
C53 a_3480_n2400.t1 VSS 0.12994f
C54 a_3480_n2400.n1 VSS 1.96957f
C55 a_3480_n2400.t0 VSS 0.18163f
C56 a_5280_n2400.n0 VSS 0.74184f
C57 a_5280_n2400.t1 VSS 0.12066f
C58 a_5280_n2400.n1 VSS 1.77114f
C59 a_5280_n2400.t0 VSS 0.16743f
C60 a_n5596_n2200.t4 VSS 0.98256f
C61 a_n5596_n2200.t0 VSS 0.13779f
C62 a_n5596_n2200.t2 VSS 0.94389f
C63 a_n5596_n2200.t1 VSS 0.93852f
C64 a_n5596_n2200.n0 VSS 0.50989f
C65 a_n5596_n2200.n1 VSS 2.02599f
C66 a_n5596_n2200.n2 VSS 0.3432f
C67 a_n5596_n2200.t3 VSS 0.97717f
C68 a_n3796_n2200.t0 VSS 0.14817f
C69 a_n3796_n2200.t4 VSS 1.01248f
C70 a_n3796_n2200.t3 VSS 1.00671f
C71 a_n3796_n2200.n0 VSS 0.5483f
C72 a_n3796_n2200.n1 VSS 2.17863f
C73 a_n3796_n2200.t1 VSS 1.04807f
C74 a_n3796_n2200.n2 VSS 0.36905f
C75 a_n3796_n2200.t2 VSS 1.05386f
C76 a_n1996_n2200.t2 VSS 0.1512f
C77 a_n1996_n2200.t4 VSS 1.01163f
C78 a_n1996_n2200.t3 VSS 1.00586f
C79 a_n1996_n2200.n0 VSS 0.54774f
C80 a_n1996_n2200.n1 VSS 2.2553f
C81 a_n1996_n2200.t0 VSS 1.04798f
C82 a_n1996_n2200.n2 VSS 0.36868f
C83 a_n1996_n2200.t1 VSS 1.05376f
C84 a_n196_n2200.t4 VSS 0.15118f
C85 a_n196_n2200.t3 VSS 1.0115f
C86 a_n196_n2200.t2 VSS 1.00574f
C87 a_n196_n2200.n0 VSS 0.54767f
C88 a_n196_n2200.n1 VSS 2.25501f
C89 a_n196_n2200.t0 VSS 1.04786f
C90 a_n196_n2200.n2 VSS 0.36863f
C91 a_n196_n2200.t1 VSS 1.05364f
C92 a_1604_n2200.t1 VSS 0.15118f
C93 a_1604_n2200.t0 VSS 1.0115f
C94 a_1604_n2200.t4 VSS 1.00574f
C95 a_1604_n2200.n0 VSS 0.54767f
C96 a_1604_n2200.n1 VSS 2.25501f
C97 a_1604_n2200.t2 VSS 1.04786f
C98 a_1604_n2200.n2 VSS 0.36863f
C99 a_1604_n2200.t3 VSS 1.05364f
C100 a_3404_n2200.t0 VSS 0.15118f
C101 a_3404_n2200.t3 VSS 1.0115f
C102 a_3404_n2200.t4 VSS 1.00574f
C103 a_3404_n2200.n0 VSS 0.54767f
C104 a_3404_n2200.n1 VSS 2.25501f
C105 a_3404_n2200.t1 VSS 1.04786f
C106 a_3404_n2200.n2 VSS 0.36863f
C107 a_3404_n2200.t2 VSS 1.05364f
C108 a_5204_n2200.t0 VSS 0.14685f
C109 a_5204_n2200.t4 VSS 0.97777f
C110 a_5204_n2200.t1 VSS 0.97217f
C111 a_5204_n2200.n0 VSS 0.53197f
C112 a_5204_n2200.n1 VSS 2.19036f
C113 a_5204_n2200.t2 VSS 1.01753f
C114 a_5204_n2200.n2 VSS 0.35806f
C115 a_5204_n2200.t3 VSS 1.02315f
C116 a_n5500_n2957.t1 VSS 0.26847f
C117 a_n5500_n2957.t3 VSS 0.30684f
C118 a_n5500_n2957.t4 VSS 0.30684f
C119 a_n5500_n2957.n0 VSS 0.92432f
C120 a_n5500_n2957.t2 VSS 0.16004f
C121 a_n5500_n2957.n1 VSS 2.75664f
C122 a_n5500_n2957.n2 VSS 0.81183f
C123 a_n5500_n2957.t0 VSS 0.26847f
C124 a_n3700_n2957.t2 VSS 0.31416f
C125 a_n3700_n2957.t0 VSS 0.16189f
C126 a_n3700_n2957.t4 VSS 0.27311f
C127 a_n3700_n2957.t3 VSS 0.27311f
C128 a_n3700_n2957.n0 VSS 0.82125f
C129 a_n3700_n2957.n1 VSS 2.78864f
C130 a_n3700_n2957.n2 VSS 0.93505f
C131 a_n3700_n2957.t1 VSS 0.31416f
C132 a_n1900_n3100.t1 VSS 0.31398f
C133 a_n1900_n3100.t2 VSS 0.16454f
C134 a_n1900_n3100.t4 VSS 0.27217f
C135 a_n1900_n3100.t3 VSS 0.27217f
C136 a_n1900_n3100.n0 VSS 0.81711f
C137 a_n1900_n3100.n1 VSS 2.86041f
C138 a_n1900_n3100.n2 VSS 0.93033f
C139 a_n1900_n3100.t0 VSS 0.31398f
C140 a_n100_n3100.t1 VSS 0.31398f
C141 a_n100_n3100.t2 VSS 0.16454f
C142 a_n100_n3100.t4 VSS 0.27217f
C143 a_n100_n3100.t3 VSS 0.27217f
C144 a_n100_n3100.n0 VSS 0.81711f
C145 a_n100_n3100.n1 VSS 2.86041f
C146 a_n100_n3100.n2 VSS 0.93033f
C147 a_n100_n3100.t0 VSS 0.31398f
C148 a_1700_n3100.t4 VSS 0.27217f
C149 a_1700_n3100.t2 VSS 0.31398f
C150 a_1700_n3100.t3 VSS 0.31398f
C151 a_1700_n3100.n0 VSS 0.93033f
C152 a_1700_n3100.t1 VSS 0.16454f
C153 a_1700_n3100.n1 VSS 2.86041f
C154 a_1700_n3100.n2 VSS 0.81711f
C155 a_1700_n3100.t0 VSS 0.27217f
C156 a_3500_n3100.t2 VSS 0.31398f
C157 a_3500_n3100.t0 VSS 0.16454f
C158 a_3500_n3100.t3 VSS 0.27217f
C159 a_3500_n3100.t4 VSS 0.27217f
C160 a_3500_n3100.n0 VSS 0.81711f
C161 a_3500_n3100.n1 VSS 2.86041f
C162 a_3500_n3100.n2 VSS 0.93033f
C163 a_3500_n3100.t1 VSS 0.31398f
C164 a_5300_n3100.t4 VSS 0.26681f
C165 a_5300_n3100.t2 VSS 0.31188f
C166 a_5300_n3100.t3 VSS 0.31188f
C167 a_5300_n3100.n0 VSS 0.93603f
C168 a_5300_n3100.t0 VSS 0.16555f
C169 a_5300_n3100.n1 VSS 2.87795f
C170 a_5300_n3100.n2 VSS 0.82211f
C171 a_5300_n3100.t1 VSS 0.26681f
C172 VSS.t28 VSS 0.05194f
C173 VSS.t18 VSS 0.05446f
C174 VSS.t11 VSS 0.05491f
C175 VSS.t6 VSS 0.05491f
C176 VSS.t29 VSS 0.05491f
C177 VSS.t19 VSS 0.05491f
C178 VSS.t34 VSS 0.05319f
C179 VDD.t18 VSS 1.44067f
C180 VDD.t19 VSS 1.29661f
C181 VDD.t10 VSS 1.29661f
C182 VDD.t11 VSS 1.29661f
C183 VDD.t6 VSS 1.29661f
C184 VDD.t7 VSS 1.29661f
C185 VDD.t2 VSS 1.29661f
C186 VDD.t3 VSS 1.29661f
C187 VDD.t22 VSS 1.29661f
C188 VDD.t23 VSS 1.29661f
C189 VDD.t14 VSS 1.29661f
C190 VDD.t15 VSS 1.29661f
C191 VDD.t26 VSS 1.29661f
C192 VDD.t27 VSS 0.73096f
C193 VDD.t25 VSS 0.10381f
C194 VDD.t13 VSS 0.10566f
C195 VDD.n0 VSS 0.16298f
C196 VDD.t24 VSS 0.95107f
C197 VDD.t20 VSS 0.65843f
C198 VDD.t21 VSS 0.10566f
C199 VDD.t1 VSS 0.10566f
C200 VDD.n1 VSS 0.16298f
C201 VDD.t4 VSS 0.65843f
C202 VDD.t5 VSS 0.10566f
C203 VDD.t9 VSS 0.10518f
C204 VDD.n2 VSS 0.16298f
C205 VDD.t16 VSS 0.68218f
C206 VDD.t17 VSS 0.10248f
C207 VDD.n3 VSS 0.70596f
C208 VDD.n4 VSS 0.11254f
C209 VDD.n5 VSS 0.67504f
C210 VDD.t8 VSS 0.65843f
C211 VDD.n6 VSS 0.67504f
C212 VDD.n7 VSS 0.11254f
C213 VDD.n8 VSS 0.16298f
C214 VDD.n9 VSS 0.11254f
C215 VDD.n10 VSS 0.67504f
C216 VDD.t0 VSS 0.65843f
C217 VDD.n11 VSS 0.67504f
C218 VDD.n12 VSS 0.11254f
C219 VDD.n13 VSS 0.16298f
C220 VDD.n14 VSS 0.11254f
C221 VDD.n15 VSS 0.67504f
C222 VDD.t12 VSS 0.65843f
C223 VDD.n16 VSS 0.67504f
C224 VDD.n17 VSS 0.11254f
C225 VDD.n18 VSS 0.38338f
C226 VDD.n19 VSS 2.04795f
C227 TERM_EN0_N.n0 VSS 0.39204f
C228 TERM_EN0_N.n1 VSS 1.70392f
C229 TERM_EN0_N.n2 VSS 0.67894f
C230 TERM_EN1_N.n0 VSS 0.41107f
C231 TERM_EN1_N.n1 VSS 1.78661f
C232 TERM_EN1_N.n2 VSS 0.71189f
C233 TERM_EN2_N.n0 VSS 0.41442f
C234 TERM_EN2_N.n1 VSS 1.80117f
C235 TERM_EN2_N.n2 VSS 0.71769f
C236 TERM_EN3_N.n0 VSS 0.41442f
C237 TERM_EN3_N.n1 VSS 1.80117f
C238 TERM_EN3_N.n2 VSS 0.71769f
C239 TERM_EN4_N.n0 VSS 0.41442f
C240 TERM_EN4_N.n1 VSS 1.80117f
C241 TERM_EN4_N.n2 VSS 0.71769f
C242 TERM_EN5_N.n0 VSS 0.41442f
C243 TERM_EN5_N.n1 VSS 1.80117f
C244 TERM_EN5_N.n2 VSS 0.71769f
C245 TERM_EN6_N.n0 VSS 0.40144f
C246 TERM_EN6_N.n1 VSS 1.74478f
C247 TERM_EN6_N.n2 VSS 0.69522f
C248 RXP.t7 VSS 0.03712f
C249 RXP.t6 VSS 0.03712f
C250 RXP.t1 VSS 0.03712f
C251 RXP.t2 VSS 0.03712f
C252 RXP.t0 VSS 0.23659f
C253 RXP.n0 VSS 1.29872f
C254 RXP.n1 VSS 0.4819f
C255 RXP.n2 VSS 0.4819f
C256 RXP.n3 VSS 0.34173f
C257 RXP.t3 VSS 0.03712f
C258 RXP.t4 VSS 0.03652f
C259 RXP.t5 VSS 0.05429f
C260 RXP.n4 VSS 0.80359f
C261 RXP.n5 VSS 0.44185f
C262 RXN.t4 VSS 0.01053f
C263 RXN.t3 VSS 0.01053f
C264 RXN.t2 VSS 0.01053f
C265 RXN.t1 VSS 0.01053f
C266 RXN.t0 VSS 0.06709f
C267 RXN.n0 VSS 0.36828f
C268 RXN.n1 VSS 0.13666f
C269 RXN.n2 VSS 0.13666f
C270 RXN.n3 VSS 0.09691f
C271 RXN.t5 VSS 0.01053f
C272 RXN.t6 VSS 0.01036f
C273 RXN.t7 VSS 0.01539f
C274 RXN.n4 VSS 0.22788f
C275 RXN.n5 VSS 0.1253f
.ends
