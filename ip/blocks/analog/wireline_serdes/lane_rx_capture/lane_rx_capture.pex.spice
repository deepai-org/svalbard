* PEX produced using /foss/tools/sak/sak-pex.sh with m=3 and s=1 (extresist threshold=0 mOhm, minres=1 mOhm, mindelay=0 ps)
* NGSPICE file created from lane_rx_capture_pex.ext - technology: gf180mcuD

.subckt lane_rx_capture_pex RXP RXN TERM_EN0_N TERM_EN1_N TERM_EN2_N TERM_EN3_N TERM_EN4_N
+ TERM_EN5_N TERM_EN6_N VTHP VTHN RX_BIAS RX_BW_EN_N REST_BIAS SAMP_CLK_P SAMP_CLK_N
+ SAMP_BIAS E_SENSE_CLK E_REGEN_CLK E_REGEN_CLKB E_CAPTURE_CLK E_CAPTURE_CLKB E_SENSE_BOOST
+ O_SENSE_CLK O_REGEN_CLK O_REGEN_CLKB O_CAPTURE_CLK O_CAPTURE_CLKB O_SENSE_BOOST
+ VDD VSS RX_RAWP RX_RAWN RX_RESTP RX_RESTN SAMP_E_P SAMP_E_N SAMP_O_P SAMP_O_N FE_E_P
+ FE_E_N FE_O_P FE_O_N EVEN_Q EVEN_QB ODD_Q ODD_QB
X0 XFRONT.XFE_O.XP.t0 XFRONT.XFE_O.SB.t13 XFRONT.XFE_O.NREGEN.t0 VSS.t31 nfet_03v3 ad=2.08p pd=8.52u as=2.08p ps=8.52u w=8u l=0.28u
X1 XCAP.O_PRST_TAIL.t5 O_CAPTURE_CLKB.t14 VDD.t518 VDD.t517 pfet_03v3 ad=2.08p pd=8.52u as=2.08p ps=8.52u w=8u l=0.28u
X2 XCAP.ODD_DB_BUF.t9 FE_O_P.t16 VSS.t185 VSS.t184 nfet_03v3 ad=2.08p pd=8.52u as=2.08p ps=8.52u w=8u l=0.28u
X3 VSS.t82 RX_BIAS.t4 a_2148_n500.t0 VSS.t71 nfet_03v3 ad=2.6p pd=10.52u as=4.4p ps=20.88u w=10u l=0.28u
X4 a_n10800_n17972.t1 TERM_EN3_N.t2 VSS.t227 VSS.t226 nfet_03v3 ad=0.44p pd=2.88u as=0.44p ps=2.88u w=1u l=0.28u
X5 a_12148_44200.t2 SAMP_O_N.t6 SAMP_O_P.t1 VSS.t125 nfet_03v3 ad=1.56p pd=6.52u as=2.64p ps=12.88u w=6u l=0.28u
X6 VSS.t278 E_CAPTURE_CLK.t3 XCAP.E_RST_TAIL.t4 VSS.t277 nfet_03v3 ad=2.08p pd=8.52u as=2.08p ps=8.52u w=8u l=0.28u
X7 XFRONT.XFE_E.VREGP.t14 XFRONT.XFE_E.XN.t51 XFRONT.XFE_E.XP.t30 VDD.t541 pfet_03v3 ad=2.08p pd=8.52u as=2.08p ps=8.52u w=8u l=0.28u
X8 VDD.t561 XFRONT.XFE_E.XP.t45 XFRONT.XFE_E.SXP.t9 VDD.t560 pfet_03v3 ad=2.08p pd=8.52u as=2.08p ps=8.52u w=8u l=0.28u
X9 XFRONT.XFE_O.SXP.t0 XFRONT.XFE_O.XP.t46 VDD.t90 VDD.t89 pfet_03v3 ad=2.08p pd=8.52u as=2.08p ps=8.52u w=8u l=0.28u
X10 FE_E_P.t10 XFRONT.XFE_E.BN.t18 VDD.t400 VDD.t399 pfet_03v3 ad=2.08p pd=8.52u as=2.08p ps=8.52u w=8u l=0.28u
X11 VDD.t308 E_CAPTURE_CLKB.t13 XCAP.E_PRST_TAIL.t4 VDD.t307 pfet_03v3 ad=2.08p pd=8.52u as=2.08p ps=8.52u w=8u l=0.28u
X12 XCAP.O_RST_TAIL.t1 O_CAPTURE_CLK.t6 VSS.t87 VSS.t86 nfet_03v3 ad=2.08p pd=8.52u as=2.08p ps=8.52u w=8u l=0.28u
X13 VSS.t25 XCAP.O_QBI.t15 XCAP.O_QBUF.t0 VSS.t24 nfet_03v3 ad=1.04p pd=4.52u as=1.76p ps=8.88u w=4u l=0.28u
X14 VDD.t289 XFRONT.XFE_E.BP.t19 FE_E_N.t7 VDD.t288 pfet_03v3 ad=2.08p pd=8.52u as=2.08p ps=8.52u w=8u l=0.28u
X15 XFRONT.XFE_E.VREGP.t5 E_REGEN_CLKB.t2 VDD.t69 VDD.t68 pfet_03v3 ad=2.08p pd=8.52u as=2.08p ps=8.52u w=8u l=0.28u
X16 VDD.t380 XFRONT.XFE_O.BP.t17 FE_O_P.t12 VDD.t379 pfet_03v3 ad=2.08p pd=8.52u as=2.08p ps=8.52u w=8u l=0.28u
X17 VDD.t171 O_REGEN_CLK.t17 XFRONT.XFE_O.XN.t11 VDD.t170 pfet_03v3 ad=2.08p pd=8.52u as=2.08p ps=8.52u w=8u l=0.28u
X18 a_n7157_n21700.t1 a_n10800_n21572.t3 a_n6400_n21652.t1 VSS.t355 nfet_03v3 ad=4.4p pd=20.88u as=2.6p ps=10.52u w=10u l=0.28u
X19 VDD.t32 FE_E_P.t23 XCAP.EVEN_DB_BUF.t2 VDD.t31 pfet_03v3 ad=2.08p pd=8.52u as=2.08p ps=8.52u w=8u l=0.28u
X20 VSS.t97 O_CAPTURE_CLK.t13 XCAP.O_SET_TAIL.t6 VSS.t96 nfet_03v3 ad=2.08p pd=8.52u as=2.08p ps=8.52u w=8u l=0.28u
X21 SAMP_E_P.t1 RX_RESTN.t5 a_948_44200.t3 VSS.t136 nfet_03v3 ad=2.64p pd=12.88u as=1.56p ps=6.52u w=6u l=0.28u
X22 XFRONT.XFE_O.NREGEN.t3 XFRONT.XFE_O.SB.t10 XFRONT.XFE_O.XP.t1 VSS.t114 nfet_03v3 ad=2.08p pd=8.52u as=2.08p ps=8.52u w=8u l=0.28u
X23 VDD.t87 E_SENSE_CLK.t3 XFRONT.XFE_E.SA.t1 VDD.t86 pfet_03v3 ad=2.08p pd=8.52u as=3.52p ps=16.88u w=8u l=0.28u
X24 VSS.t311 FE_E_N.t17 XCAP.EVEN_D_BUF.t8 VSS.t310 nfet_03v3 ad=2.08p pd=8.52u as=3.52p ps=16.88u w=8u l=0.28u
X25 XFRONT.XFE_E.VREGN.t7 E_REGEN_CLKB.t8 VDD.t49 VDD.t48 pfet_03v3 ad=3.52p pd=16.88u as=2.08p ps=8.52u w=8u l=0.28u
X26 a_2148_n500.t8 a_n6572_3500.t7 RX_RAWP.t3 VSS.t158 nfet_03v3 ad=1.3p pd=5.52u as=2.2p ps=10.88u w=5u l=0.28u
X27 XFRONT.XFE_O.SXN.t0 XFRONT.XFE_O.XN.t38 VSS.t168 VSS.t167 nfet_03v3 ad=3.52p pd=16.88u as=2.08p ps=8.52u w=8u l=0.28u
X28 VDD.t253 E_REGEN_CLK.t13 XFRONT.XFE_E.XP.t11 VDD.t252 pfet_03v3 ad=2.08p pd=8.52u as=2.08p ps=8.52u w=8u l=0.28u
X29 VDD.t485 XFRONT.XFE_O.XN.t47 XFRONT.XFE_O.SXN.t8 VDD.t484 pfet_03v3 ad=2.08p pd=8.52u as=2.08p ps=8.52u w=8u l=0.28u
X30 XCAP.E_RST_TAIL.t7 E_CAPTURE_CLK.t0 VSS.t284 VSS.t283 nfet_03v3 ad=3.52p pd=16.88u as=2.08p ps=8.52u w=8u l=0.28u
X31 VDD.t259 E_REGEN_CLK.t9 XFRONT.XFE_E.NREGEN.t13 VDD.t258 pfet_03v3 ad=2.08p pd=8.52u as=3.52p ps=16.88u w=8u l=0.28u
X32 XFRONT.XFE_E.VREGN.t10 XFRONT.XFE_E.XP.t55 XFRONT.XFE_E.XN.t26 VDD.t370 pfet_03v3 ad=2.08p pd=8.52u as=2.08p ps=8.52u w=8u l=0.28u
X33 XFRONT.XFE_E.XP.t33 XFRONT.XFE_E.XN.t54 XFRONT.XFE_E.VREGP.t11 VDD.t570 pfet_03v3 ad=2.08p pd=8.52u as=2.08p ps=8.52u w=8u l=0.28u
X34 VDD.t531 O_CAPTURE_CLKB.t1 XCAP.O_PSET_TAIL.t10 VDD.t523 pfet_03v3 ad=2.08p pd=8.52u as=2.08p ps=8.52u w=8u l=0.28u
X35 a_n5052_2600.t6 VTHN.t1 a_n3600_5641.t2 VSS.t215 nfet_03v3 ad=0.52p pd=2.52u as=0.88p ps=4.88u w=2u l=0.28u
X36 VSS.t403 XFRONT.XFE_E.SXN.t15 XFRONT.XFE_E.BN.t6 VSS.t402 nfet_03v3 ad=2.08p pd=8.52u as=2.08p ps=8.52u w=8u l=0.28u
X37 VDD.t138 XFRONT.XFE_O.XP.t43 XFRONT.XFE_O.SXP.t5 VDD.t137 pfet_03v3 ad=2.08p pd=8.52u as=2.08p ps=8.52u w=8u l=0.28u
X38 VSS.t217 O_REGEN_CLK.t7 XFRONT.XFE_O.NREGEN.t18 VSS.t216 nfet_03v3 ad=2.08p pd=8.52u as=3.52p ps=16.88u w=8u l=0.28u
X39 XFRONT.XFE_O.BN.t1 XFRONT.XFE_O.SXN.t20 VDD.t350 VDD.t349 pfet_03v3 ad=3.52p pd=16.88u as=2.08p ps=8.52u w=8u l=0.28u
X40 RX_RESTN.t0 a_600_22678.t3 a_n852_28800.t0 VSS.t62 nfet_03v3 ad=4.4p pd=20.88u as=2.6p ps=10.52u w=10u l=0.28u
X41 FE_E_N.t4 XFRONT.XFE_E.BP.t16 VDD.t283 VDD.t282 pfet_03v3 ad=3.52p pd=16.88u as=2.08p ps=8.52u w=8u l=0.28u
X42 VDD.t47 E_REGEN_CLKB.t5 XFRONT.XFE_E.VREGP.t2 VDD.t46 pfet_03v3 ad=2.08p pd=8.52u as=2.08p ps=8.52u w=8u l=0.28u
X43 VSS.t69 RX_BIAS.t13 a_n5052_2600.t0 VSS.t68 nfet_03v3 ad=0.52p pd=2.52u as=0.88p ps=4.88u w=2u l=0.28u
X44 XCAP.ODD_D_BUF.t3 FE_O_N.t22 VDD.t476 VDD.t97 pfet_03v3 ad=2.08p pd=8.52u as=2.08p ps=8.52u w=8u l=0.28u
X45 VSS.t484 XCAP.E_QI.t15 XCAP.E_QBBUF.t2 VSS.t312 nfet_03v3 ad=1.04p pd=4.52u as=1.76p ps=8.88u w=4u l=0.28u
X46 XCAP.E_PSET_TAIL.t7 E_CAPTURE_CLKB.t0 VDD.t321 VDD.t315 pfet_03v3 ad=3.52p pd=16.88u as=2.08p ps=8.52u w=8u l=0.28u
X47 XCAP.O_SET_TAIL.t9 O_CAPTURE_CLK.t10 VSS.t103 VSS.t102 nfet_03v3 ad=2.08p pd=8.52u as=2.08p ps=8.52u w=8u l=0.28u
X48 FE_E_P.t4 XFRONT.XFE_E.BN.t12 VSS.t205 VSS.t204 nfet_03v3 ad=2.08p pd=8.52u as=2.08p ps=8.52u w=8u l=0.28u
X49 VDD.t305 E_CAPTURE_CLKB.t7 XCAP.E_PSET_TAIL.t0 VDD.t304 pfet_03v3 ad=2.08p pd=8.52u as=3.52p ps=16.88u w=8u l=0.28u
X50 a_n6400_n18052.t4 a_n10800_n17972.t2 a_n7300_n18100.t4 VSS.t496 nfet_03v3 ad=2.6p pd=10.52u as=4.4p ps=20.88u w=10u l=0.28u
X51 XCAP.O_PRST_TAIL.t1 XCAP.ODD_D_BUF.t19 XCAP.O_QBI.t5 VDD.t41 pfet_03v3 ad=2.08p pd=8.52u as=3.52p ps=16.88u w=8u l=0.28u
X52 VDD.t434 O_REGEN_CLKB.t13 XFRONT.XFE_O.VREGP.t2 VDD.t433 pfet_03v3 ad=2.08p pd=8.52u as=2.08p ps=8.52u w=8u l=0.28u
X53 XFRONT.XFE_E.NREGEN.t29 XFRONT.XFE_E.XN.t36 XFRONT.XFE_E.XP.t23 VSS.t486 nfet_03v3 ad=2.08p pd=8.52u as=2.08p ps=8.52u w=8u l=0.28u
X54 VDD.t554 XCAP.O_QBI.t19 XCAP.O_QBUF.t3 VDD.t553 pfet_03v3 ad=2.08p pd=8.52u as=3.52p ps=16.88u w=8u l=0.28u
X55 a_600_22678.t1 RX_RAWN.t4 a_n852_19400.t6 VSS.t62 nfet_03v3 ad=4.4p pd=20.88u as=2.6p ps=10.52u w=10u l=0.28u
X56 XFRONT.XFE_E.SXN.t7 XFRONT.XFE_E.XN.t38 VSS.t489 VSS.t488 nfet_03v3 ad=3.52p pd=16.88u as=2.08p ps=8.52u w=8u l=0.28u
X57 XFRONT.XFE_E.SB.t0 VSS.t512 VDD.t163 VDD.t162 pfet_03v3 ad=3.52p pd=16.88u as=3.52p ps=16.88u w=8u l=0.28u
X58 VSS.t365 XFRONT.XFE_O.SXP.t13 XFRONT.XFE_O.BP.t8 VSS.t364 nfet_03v3 ad=2.08p pd=8.52u as=2.08p ps=8.52u w=8u l=0.28u
X59 XFRONT.XFE_E.BN.t3 XFRONT.XFE_E.SXN.t18 VSS.t409 VSS.t408 nfet_03v3 ad=2.08p pd=8.52u as=2.08p ps=8.52u w=8u l=0.28u
X60 XCAP.E_PRST_TAIL.t1 XCAP.EVEN_D_BUF.t17 XCAP.E_QBI.t1 VDD.t7 pfet_03v3 ad=2.08p pd=8.52u as=2.08p ps=8.52u w=8u l=0.28u
X61 a_n852_19400.t5 REST_BIAS.t0 VSS.t432 VSS.t427 nfet_03v3 ad=5.28p pd=24.88u as=3.12p ps=12.52u w=12u l=0.28u
X62 VDD.t17 XCAP.O_QI.t17 XCAP.O_QBI.t8 VDD.t16 pfet_03v3 ad=2.08p pd=8.52u as=3.52p ps=16.88u w=8u l=0.28u
X63 XFRONT.XFE_O.VREGN.t11 O_REGEN_CLKB.t4 VDD.t452 VDD.t451 pfet_03v3 ad=2.08p pd=8.52u as=2.08p ps=8.52u w=8u l=0.28u
X64 a_n6400_n12652.t0 RXN.t3 VSS.t150 ppolyf_u r_width=1u r_length=1u
X65 VSS.t244 E_REGEN_CLK.t7 XFRONT.XFE_E.NREGEN.t15 VSS.t243 nfet_03v3 ad=2.08p pd=8.52u as=3.52p ps=16.88u w=8u l=0.28u
X66 RXP.t4 a_n7157_n23500.t1 VSS.t2 ppolyf_u r_width=1u r_length=2.43u
X67 VSS.t329 XFRONT.XFE_E.XP.t39 XFRONT.XFE_E.SXP.t6 VSS.t328 nfet_03v3 ad=2.08p pd=8.52u as=2.08p ps=8.52u w=8u l=0.28u
X68 XCAP.E_RST_TAIL.t1 E_CAPTURE_CLK.t6 VSS.t274 VSS.t273 nfet_03v3 ad=2.08p pd=8.52u as=2.08p ps=8.52u w=8u l=0.28u
X69 a_n5052_2600.t1 RX_BIAS.t12 VSS.t70 VSS.t68 nfet_03v3 ad=0.52p pd=2.52u as=0.52p ps=2.52u w=2u l=0.28u
X70 XFRONT.XFE_O.SXP.t8 XFRONT.XFE_O.XP.t40 VSS.t347 VSS.t346 nfet_03v3 ad=2.08p pd=8.52u as=2.08p ps=8.52u w=8u l=0.28u
X71 XCAP.EVEN_D_BUF.t1 FE_E_N.t24 VDD.t323 VDD.t322 pfet_03v3 ad=2.08p pd=8.52u as=2.08p ps=8.52u w=8u l=0.28u
X72 XFRONT.XFE_E.SXP.t10 XFRONT.XFE_E.XP.t46 VDD.t563 VDD.t562 pfet_03v3 ad=2.08p pd=8.52u as=2.08p ps=8.52u w=8u l=0.28u
X73 XCAP.E_QBI.t7 XCAP.E_QI.t16 VDD.t496 VDD.t300 pfet_03v3 ad=3.52p pd=16.88u as=2.08p ps=8.52u w=8u l=0.28u
X74 VSS.t144 XCAP.O_QBBUF.t6 ODD_Q.t3 VSS.t143 nfet_03v3 ad=2.08p pd=8.52u as=3.52p ps=16.88u w=8u l=0.28u
X75 XCAP.EVEN_DB_BUF.t9 FE_E_P.t16 VSS.t52 VSS.t51 nfet_03v3 ad=2.08p pd=8.52u as=2.08p ps=8.52u w=8u l=0.28u
X76 VDD.t225 E_REGEN_CLK.t29 XFRONT.XFE_E.XN.t12 VDD.t224 pfet_03v3 ad=2.08p pd=8.52u as=2.08p ps=8.52u w=8u l=0.28u
X77 XFRONT.XFE_O.XN.t2 XFRONT.XFE_O.SA.t7 XFRONT.XFE_O.NREGEN.t6 VSS.t131 nfet_03v3 ad=3.52p pd=16.88u as=2.08p ps=8.52u w=8u l=0.28u
X78 EVEN_QB.t3 XCAP.E_QBUF.t9 VDD.t43 VDD.t42 pfet_03v3 ad=2.08p pd=8.52u as=2.08p ps=8.52u w=8u l=0.28u
X79 a_n852_28800.t7 REST_BIAS.t4 VSS.t428 VSS.t427 nfet_03v3 ad=5.28p pd=24.88u as=3.12p ps=12.52u w=12u l=0.28u
X80 VDD.t13 XCAP.O_QBBUF.t10 ODD_Q.t2 VDD.t12 pfet_03v3 ad=2.08p pd=8.52u as=3.52p ps=16.88u w=8u l=0.28u
X81 VDD.t527 O_CAPTURE_CLKB.t5 XCAP.O_PSET_TAIL.t6 VDD.t519 pfet_03v3 ad=2.08p pd=8.52u as=2.08p ps=8.52u w=8u l=0.28u
X82 FE_O_P.t9 XFRONT.XFE_O.BP.t14 VSS.t293 VSS.t292 nfet_03v3 ad=2.08p pd=8.52u as=2.08p ps=8.52u w=8u l=0.28u
X83 XCAP.EVEN_D_BUF.t11 FE_E_N.t14 VSS.t309 VSS.t308 nfet_03v3 ad=3.52p pd=16.88u as=2.08p ps=8.52u w=8u l=0.28u
X84 VDD.t458 O_REGEN_CLKB.t1 XFRONT.XFE_O.VREGN.t14 VDD.t457 pfet_03v3 ad=2.08p pd=8.52u as=2.08p ps=8.52u w=8u l=0.28u
X85 VSS.t473 XFRONT.XFE_O.XN.t41 XFRONT.XFE_O.SXN.t11 VSS.t472 nfet_03v3 ad=2.08p pd=8.52u as=3.52p ps=16.88u w=8u l=0.28u
X86 XFRONT.XFE_E.XN.t23 XFRONT.XFE_E.XP.t52 XFRONT.XFE_E.VREGN.t13 VDD.t371 pfet_03v3 ad=2.08p pd=8.52u as=2.08p ps=8.52u w=8u l=0.28u
X87 XFRONT.XFE_E.NTAIL.t3 SAMP_E_P.t8 XFRONT.XFE_E.SB.t5 VSS.t139 nfet_03v3 ad=2.08p pd=8.52u as=3.52p ps=16.88u w=8u l=0.28u
X88 a_n10800_n23372.t1 TERM_EN0_N.t2 VSS.t351 VSS.t226 nfet_03v3 ad=0.44p pd=2.88u as=0.44p ps=2.88u w=1u l=0.28u
X89 XFRONT.XFE_E.NREGEN.t1 XFRONT.XFE_E.SB.t10 XFRONT.XFE_E.XP.t0 VSS.t16 nfet_03v3 ad=2.08p pd=8.52u as=2.08p ps=8.52u w=8u l=0.28u
X90 XFRONT.XFE_E.BN.t9 XFRONT.XFE_E.SXN.t12 VSS.t411 VSS.t410 nfet_03v3 ad=3.52p pd=16.88u as=2.08p ps=8.52u w=8u l=0.28u
X91 VDD.t473 FE_O_N.t19 XCAP.ODD_D_BUF.t6 VDD.t472 pfet_03v3 ad=2.08p pd=8.52u as=2.08p ps=8.52u w=8u l=0.28u
X92 XFRONT.XFE_E.BN.t1 XFRONT.XFE_E.SXN.t20 VDD.t396 VDD.t395 pfet_03v3 ad=3.52p pd=16.88u as=2.08p ps=8.52u w=8u l=0.28u
X93 XCAP.O_QBI.t6 XCAP.ODD_D_BUF.t16 XCAP.O_PRST_TAIL.t2 VDD.t141 pfet_03v3 ad=3.52p pd=16.88u as=2.08p ps=8.52u w=8u l=0.28u
X94 a_n7300_n14500.t0 TERM_EN5_N.t1 a_n6400_n14452.t2 VDD.t292 pfet_03v3 ad=4.4p pd=20.88u as=2.6p ps=10.52u w=10u l=0.28u
X95 XFRONT.XFE_E.XN.t9 E_REGEN_CLK.t32 VDD.t233 VDD.t78 pfet_03v3 ad=2.08p pd=8.52u as=2.08p ps=8.52u w=8u l=0.28u
X96 XCAP.O_RST_TAIL.t3 O_CAPTURE_CLK.t4 VSS.t107 VSS.t27 nfet_03v3 ad=2.08p pd=8.52u as=2.08p ps=8.52u w=8u l=0.28u
X97 VSS.t287 XFRONT.XFE_O.BP.t11 FE_O_P.t6 VSS.t286 nfet_03v3 ad=2.08p pd=8.52u as=2.08p ps=8.52u w=8u l=0.28u
X98 a_10548_44200.t5 SAMP_CLK_N.t0 a_11748_41600.t2 VSS.t441 nfet_03v3 ad=3.52p pd=16.88u as=2.08p ps=8.52u w=8u l=0.28u
X99 VDD.t100 XCAP.E_QBI.t19 XCAP.E_QBUF.t0 VDD.t99 pfet_03v3 ad=2.08p pd=8.52u as=3.52p ps=16.88u w=8u l=0.28u
X100 FE_E_N.t2 XFRONT.XFE_E.BP.t14 VSS.t212 VSS.t211 nfet_03v3 ad=2.08p pd=8.52u as=2.08p ps=8.52u w=8u l=0.28u
X101 XFRONT.XFE_E.NTAIL.t1 E_SENSE_CLK.t0 VSS.t118 VSS.t117 nfet_03v3 ad=3.52p pd=16.88u as=2.08p ps=8.52u w=8u l=0.28u
X102 VDD.t539 XFRONT.XFE_E.XN.t49 XFRONT.XFE_E.SXN.t9 VDD.t538 pfet_03v3 ad=2.08p pd=8.52u as=3.52p ps=16.88u w=8u l=0.28u
X103 XFRONT.XFE_O.NREGEN.t15 O_REGEN_CLK.t10 VDD.t207 VDD.t206 pfet_03v3 ad=3.52p pd=16.88u as=2.08p ps=8.52u w=8u l=0.28u
X104 XFRONT.XFE_E.XP.t4 XFRONT.XFE_E.SB.t13 XFRONT.XFE_E.NREGEN.t9 VSS.t170 nfet_03v3 ad=2.08p pd=8.52u as=2.08p ps=8.52u w=8u l=0.28u
X105 VDD.t201 O_REGEN_CLK.t15 XFRONT.XFE_O.XN.t13 VDD.t200 pfet_03v3 ad=2.08p pd=8.52u as=2.08p ps=8.52u w=8u l=0.28u
X106 XFRONT.XFE_O.XN.t26 XFRONT.XFE_O.SA.t13 XFRONT.XFE_O.NREGEN.t27 VSS.t417 nfet_03v3 ad=2.08p pd=8.52u as=2.08p ps=8.52u w=8u l=0.28u
X107 XFRONT.XFE_O.BP.t5 XFRONT.XFE_O.SXP.t16 VSS.t371 VSS.t370 nfet_03v3 ad=2.08p pd=8.52u as=2.08p ps=8.52u w=8u l=0.28u
X108 XFRONT.XFE_O.NREGEN.t29 XFRONT.XFE_O.SB.t8 XFRONT.XFE_O.XP.t22 VSS.t420 nfet_03v3 ad=2.08p pd=8.52u as=2.08p ps=8.52u w=8u l=0.28u
X109 a_n5052_n1000.t3 RX_BIAS.t8 VSS.t79 VSS.t74 nfet_03v3 ad=2.6p pd=10.52u as=2.6p ps=10.52u w=10u l=0.28u
X110 a_n10800_n12572.t0 TERM_EN6_N.t3 VDD.t217 VDD.t216 pfet_03v3 ad=0.88p pd=4.88u as=0.88p ps=4.88u w=2u l=0.28u
X111 XCAP.O_QI.t2 XCAP.O_QBI.t12 VSS.t196 VSS.t100 nfet_03v3 ad=3.52p pd=16.88u as=2.08p ps=8.52u w=8u l=0.28u
X112 VDD.t481 XFRONT.XFE_O.XN.t45 XFRONT.XFE_O.SXN.t6 VDD.t480 pfet_03v3 ad=2.08p pd=8.52u as=2.08p ps=8.52u w=8u l=0.28u
X113 XFRONT.XFE_E.VREGN.t3 E_REGEN_CLKB.t12 VDD.t51 VDD.t50 pfet_03v3 ad=2.08p pd=8.52u as=2.08p ps=8.52u w=8u l=0.28u
X114 XFRONT.XFE_E.XP.t25 XFRONT.XFE_E.XN.t56 XFRONT.XFE_E.VREGP.t9 VDD.t532 pfet_03v3 ad=2.08p pd=8.52u as=2.08p ps=8.52u w=8u l=0.28u
X115 XCAP.O_QBBUF.t3 XCAP.O_QI.t14 VSS.t30 VSS.t29 nfet_03v3 ad=1.76p pd=8.88u as=1.04p ps=4.52u w=4u l=0.28u
X116 XFRONT.XFE_O.NTAIL.t7 SAMP_O_P.t8 XFRONT.XFE_O.SA.t1 VSS.t119 nfet_03v3 ad=2.08p pd=8.52u as=3.52p ps=16.88u w=8u l=0.28u
X117 VDD.t153 XFRONT.XFE_E.BN.t23 FE_E_P.t1 VDD.t152 pfet_03v3 ad=2.08p pd=8.52u as=3.52p ps=16.88u w=8u l=0.28u
X118 a_n7300_n18100.t0 TERM_EN3_N.t1 a_n6400_n18052.t2 VDD.t214 pfet_03v3 ad=4.4p pd=20.88u as=2.6p ps=10.52u w=10u l=0.28u
X119 XFRONT.XFE_E.NREGEN.t0 XFRONT.XFE_E.SA.t14 XFRONT.XFE_E.XN.t0 VSS.t15 nfet_03v3 ad=2.08p pd=8.52u as=3.52p ps=16.88u w=8u l=0.28u
X120 VSS.t111 O_CAPTURE_CLK.t1 XCAP.O_RST_TAIL.t6 VSS.t110 nfet_03v3 ad=2.08p pd=8.52u as=2.08p ps=8.52u w=8u l=0.28u
X121 RX_RAWP.t2 RX_BW_EN_N.t1 a_484_3500.t1 VDD.t427 pfet_03v3 ad=2.2p pd=10.88u as=2.2p ps=10.88u w=5u l=0.28u
X122 a_n6400_n16252.t0 RXN.t1 VSS.t130 ppolyf_u r_width=1u r_length=1u
X123 XFRONT.XFE_O.BN.t4 XFRONT.XFE_O.SXN.t16 VSS.t383 VSS.t382 nfet_03v3 ad=2.08p pd=8.52u as=2.08p ps=8.52u w=8u l=0.28u
X124 XFRONT.XFE_E.SXP.t7 XFRONT.XFE_E.XP.t40 VSS.t331 VSS.t330 nfet_03v3 ad=2.08p pd=8.52u as=2.08p ps=8.52u w=8u l=0.28u
X125 XCAP.O_PRST_TAIL.t7 O_CAPTURE_CLKB.t12 VDD.t521 VDD.t16 pfet_03v3 ad=2.08p pd=8.52u as=2.08p ps=8.52u w=8u l=0.28u
X126 VDD.t65 E_REGEN_CLKB.t7 XFRONT.XFE_E.VREGP.t0 VDD.t64 pfet_03v3 ad=2.08p pd=8.52u as=3.52p ps=16.88u w=8u l=0.28u
X127 a_n6400_n23452.t0 a_n10800_n23372.t2 a_n7157_n23500.t0 VSS.t197 nfet_03v3 ad=2.6p pd=10.52u as=4.4p ps=20.88u w=10u l=0.28u
X128 VSS.t259 E_CAPTURE_CLK.t15 XCAP.E_SET_TAIL.t2 VSS.t258 nfet_03v3 ad=2.08p pd=8.52u as=3.52p ps=16.88u w=8u l=0.28u
X129 XFRONT.XFE_O.XN.t16 O_REGEN_CLK.t12 VDD.t205 VDD.t204 pfet_03v3 ad=3.52p pd=16.88u as=2.08p ps=8.52u w=8u l=0.28u
X130 XFRONT.XFE_O.NREGEN.t28 XFRONT.XFE_O.SA.t10 XFRONT.XFE_O.XN.t27 VSS.t418 nfet_03v3 ad=2.08p pd=8.52u as=2.08p ps=8.52u w=8u l=0.28u
X131 VDD.t368 XFRONT.XFE_O.BN.t19 FE_O_N.t9 VDD.t367 pfet_03v3 ad=2.08p pd=8.52u as=2.08p ps=8.52u w=8u l=0.28u
X132 ODD_QB.t2 XCAP.O_QBUF.t5 VSS.t155 VSS.t154 nfet_03v3 ad=2.08p pd=8.52u as=2.08p ps=8.52u w=8u l=0.28u
X133 XCAP.O_SET_TAIL.t11 O_CAPTURE_CLK.t8 VSS.t89 VSS.t88 nfet_03v3 ad=3.52p pd=16.88u as=2.08p ps=8.52u w=8u l=0.28u
X134 EVEN_Q.t5 XCAP.E_QBBUF.t7 VDD.t509 VDD.t508 pfet_03v3 ad=3.52p pd=16.88u as=2.08p ps=8.52u w=8u l=0.28u
X135 XCAP.E_QI.t4 XCAP.EVEN_DB_BUF.t18 XCAP.E_PSET_TAIL.t11 VDD.t129 pfet_03v3 ad=2.08p pd=8.52u as=2.08p ps=8.52u w=8u l=0.28u
X136 XFRONT.XFE_E.XP.t6 E_REGEN_CLK.t18 VDD.t246 VDD.t245 pfet_03v3 ad=2.08p pd=8.52u as=2.08p ps=8.52u w=8u l=0.28u
X137 VDD.t440 O_REGEN_CLKB.t11 XFRONT.XFE_O.VREGP.t4 VDD.t439 pfet_03v3 ad=2.08p pd=8.52u as=2.08p ps=8.52u w=8u l=0.28u
X138 XFRONT.XFE_O.XN.t23 O_REGEN_CLK.t27 XFRONT.XFE_O.XP.t14 VDD.t184 pfet_03v3 ad=2.08p pd=8.52u as=3.52p ps=16.88u w=8u l=0.28u
X139 RX_RAWN.t1 a_n3600_5641.t6 a_2148_n500.t5 VSS.t158 nfet_03v3 ad=2.2p pd=10.88u as=1.3p ps=5.52u w=5u l=0.28u
X140 XFRONT.XFE_O.SXN.t3 XFRONT.XFE_O.XN.t42 VDD.t420 VDD.t419 pfet_03v3 ad=3.52p pd=16.88u as=2.08p ps=8.52u w=8u l=0.28u
X141 VDD.t312 E_CAPTURE_CLKB.t11 XCAP.E_PRST_TAIL.t6 VDD.t300 pfet_03v3 ad=2.08p pd=8.52u as=2.08p ps=8.52u w=8u l=0.28u
X142 a_n1900_5958.t1 RX_BW_EN_N.t2 a_n3600_5641.t5 VDD.t426 pfet_03v3 ad=2.2p pd=10.88u as=2.2p ps=10.88u w=5u l=0.28u
X143 a_n6400_n12652.t2 TERM_EN6_N.t0 a_n7300_n12700.t2 VDD.t219 pfet_03v3 ad=2.6p pd=10.52u as=4.4p ps=20.88u w=10u l=0.28u
X144 XCAP.E_RST_TAIL.t11 XCAP.EVEN_DB_BUF.t15 XCAP.E_QI.t7 VSS.t262 nfet_03v3 ad=2.08p pd=8.52u as=3.52p ps=16.88u w=8u l=0.28u
X145 VDD.t157 VSS.t509 XFRONT.XFE_O.SB.t0 VDD.t156 pfet_03v3 ad=3.52p pd=16.88u as=3.52p ps=16.88u w=8u l=0.28u
X146 XFRONT.XFE_O.NREGEN.t33 XFRONT.XFE_O.XP.t37 XFRONT.XFE_O.XN.t34 VSS.t500 nfet_03v3 ad=2.08p pd=8.52u as=3.52p ps=16.88u w=8u l=0.28u
X147 XFRONT.XFE_E.XP.t3 XFRONT.XFE_E.SB.t7 XFRONT.XFE_E.NREGEN.t8 VSS.t169 nfet_03v3 ad=3.52p pd=16.88u as=2.08p ps=8.52u w=8u l=0.28u
X148 VSS.t397 XFRONT.XFE_O.SXN.t13 XFRONT.XFE_O.BN.t8 VSS.t396 nfet_03v3 ad=2.08p pd=8.52u as=2.08p ps=8.52u w=8u l=0.28u
X149 VDD.t26 FE_E_P.t25 XCAP.EVEN_DB_BUF.t0 VDD.t25 pfet_03v3 ad=2.08p pd=8.52u as=3.52p ps=16.88u w=8u l=0.28u
X150 XCAP.EVEN_DB_BUF.t7 FE_E_P.t18 VDD.t40 VDD.t39 pfet_03v3 ad=3.52p pd=16.88u as=2.08p ps=8.52u w=8u l=0.28u
X151 VDD.t79 E_SENSE_CLK.t7 XFRONT.XFE_E.SB.t1 VDD.t78 pfet_03v3 ad=2.08p pd=8.52u as=3.52p ps=16.88u w=8u l=0.28u
X152 VDD.t122 FE_O_P.t19 XCAP.ODD_DB_BUF.t6 VDD.t121 pfet_03v3 ad=2.08p pd=8.52u as=2.08p ps=8.52u w=8u l=0.28u
X153 SAMP_E_N.t2 RX_RESTP.t5 a_948_44200.t1 VSS.t65 nfet_03v3 ad=2.64p pd=12.88u as=1.56p ps=6.52u w=6u l=0.28u
X154 RXP.t3 a_n7300_n12700.t0 VSS.t2 ppolyf_u r_width=1u r_length=1u
X155 FE_O_N.t6 XFRONT.XFE_O.BN.t16 VDD.t362 VDD.t361 pfet_03v3 ad=3.52p pd=16.88u as=2.08p ps=8.52u w=8u l=0.28u
X156 XCAP.E_RST_TAIL.t3 E_CAPTURE_CLK.t4 VSS.t276 VSS.t59 nfet_03v3 ad=2.08p pd=8.52u as=2.08p ps=8.52u w=8u l=0.28u
X157 XFRONT.XFE_E.XP.t29 XFRONT.XFE_E.XN.t50 XFRONT.XFE_E.VREGP.t15 VDD.t540 pfet_03v3 ad=3.52p pd=16.88u as=2.08p ps=8.52u w=8u l=0.28u
X158 a_n6400_n19852.t2 RXN.t6 VSS.t350 ppolyf_u r_width=1u r_length=1u
X159 XFRONT.XFE_E.SXP.t4 XFRONT.XFE_E.XP.t44 VDD.t275 VDD.t274 pfet_03v3 ad=2.08p pd=8.52u as=2.08p ps=8.52u w=8u l=0.28u
X160 XFRONT.XFE_O.VREGP.t7 O_REGEN_CLKB.t8 VDD.t446 VDD.t445 pfet_03v3 ad=3.52p pd=16.88u as=2.08p ps=8.52u w=8u l=0.28u
X161 VSS.t327 XFRONT.XFE_E.SXP.t13 XFRONT.XFE_E.BP.t1 VSS.t326 nfet_03v3 ad=2.08p pd=8.52u as=2.08p ps=8.52u w=8u l=0.28u
X162 a_n6572_3500.t5 RX_BW_EN_N.t3 a_n6716_3500.t1 VDD.t425 pfet_03v3 ad=2.2p pd=10.88u as=2.2p ps=10.88u w=5u l=0.28u
X163 SAMP_O_N.t4 SAMP_O_P.t5 a_12148_44200.t1 VSS.t122 nfet_03v3 ad=2.64p pd=12.88u as=1.56p ps=6.52u w=6u l=0.28u
X164 VDD.t277 XCAP.O_QBUF.t10 ODD_QB.t5 VDD.t276 pfet_03v3 ad=2.08p pd=8.52u as=3.52p ps=16.88u w=8u l=0.28u
X165 XFRONT.XFE_O.SB.t4 O_SENSE_CLK.t2 VDD.t297 VDD.t200 pfet_03v3 ad=3.52p pd=16.88u as=2.08p ps=8.52u w=8u l=0.28u
X166 VSS.t337 XFRONT.XFE_O.BN.t11 FE_O_N.t1 VSS.t336 nfet_03v3 ad=2.08p pd=8.52u as=2.08p ps=8.52u w=8u l=0.28u
X167 VDD.t499 XCAP.E_QI.t19 XCAP.E_QBBUF.t0 VDD.t328 pfet_03v3 ad=2.08p pd=8.52u as=3.52p ps=16.88u w=8u l=0.28u
X168 XFRONT.XFE_E.XN.t14 E_REGEN_CLK.t27 XFRONT.XFE_E.XP.t14 VDD.t237 pfet_03v3 ad=2.08p pd=8.52u as=3.52p ps=16.88u w=8u l=0.28u
X169 XFRONT.XFE_O.XN.t10 O_REGEN_CLK.t18 VDD.t195 VDD.t194 pfet_03v3 ad=2.08p pd=8.52u as=2.08p ps=8.52u w=8u l=0.28u
X170 XFRONT.XFE_O.XP.t4 XFRONT.XFE_O.SB.t11 XFRONT.XFE_O.NREGEN.t9 VSS.t163 nfet_03v3 ad=2.08p pd=8.52u as=2.08p ps=8.52u w=8u l=0.28u
X171 XCAP.O_SET_TAIL.t5 O_CAPTURE_CLK.t14 VSS.t95 VSS.t94 nfet_03v3 ad=2.08p pd=8.52u as=2.08p ps=8.52u w=8u l=0.28u
X172 VSS.t83 RX_BIAS.t2 a_2148_n500.t2 VSS.t71 nfet_03v3 ad=2.6p pd=10.52u as=2.6p ps=10.52u w=10u l=0.28u
X173 VDD.t20 SAMP_O_P.t0 VSS.t43 ppolyf_u r_width=2u r_length=5u
X174 XFRONT.XFE_O.NTAIL.t1 O_SENSE_BOOST.t4 VSS.t10 VSS.t9 nfet_03v3 ad=2.08p pd=8.52u as=2.08p ps=8.52u w=8u l=0.28u
X175 VDD.t343 XFRONT.XFE_O.SXP.t21 XFRONT.XFE_O.BP.t0 VDD.t342 pfet_03v3 ad=2.08p pd=8.52u as=3.52p ps=16.88u w=8u l=0.28u
X176 XFRONT.XFE_E.XP.t12 E_REGEN_CLK.t12 VDD.t255 VDD.t254 pfet_03v3 ad=3.52p pd=16.88u as=2.08p ps=8.52u w=8u l=0.28u
X177 VSS.t469 XFRONT.XFE_O.XN.t39 XFRONT.XFE_O.SXN.t9 VSS.t468 nfet_03v3 ad=2.08p pd=8.52u as=2.08p ps=8.52u w=8u l=0.28u
X178 FE_E_N.t10 XFRONT.XFE_E.BP.t22 VDD.t388 VDD.t387 pfet_03v3 ad=2.08p pd=8.52u as=2.08p ps=8.52u w=8u l=0.28u
X179 XFRONT.XFE_O.SXN.t1 XFRONT.XFE_O.XN.t48 VDD.t415 VDD.t414 pfet_03v3 ad=2.08p pd=8.52u as=2.08p ps=8.52u w=8u l=0.28u
X180 VDD.t524 O_CAPTURE_CLKB.t9 XCAP.O_PRST_TAIL.t10 VDD.t523 pfet_03v3 ad=2.08p pd=8.52u as=2.08p ps=8.52u w=8u l=0.28u
X181 VSS.t282 E_CAPTURE_CLK.t1 XCAP.E_RST_TAIL.t6 VSS.t281 nfet_03v3 ad=2.08p pd=8.52u as=2.08p ps=8.52u w=8u l=0.28u
X182 XFRONT.XFE_E.VREGP.t12 XFRONT.XFE_E.XN.t53 XFRONT.XFE_E.XP.t28 VDD.t535 pfet_03v3 ad=2.08p pd=8.52u as=2.08p ps=8.52u w=8u l=0.28u
X183 XFRONT.XFE_E.NREGEN.t14 E_REGEN_CLK.t8 VDD.t261 VDD.t260 pfet_03v3 ad=3.52p pd=16.88u as=2.08p ps=8.52u w=8u l=0.28u
X184 a_n10800_n16172.t0 TERM_EN4_N.t3 VDD.t462 VDD.t461 pfet_03v3 ad=0.88p pd=4.88u as=0.88p ps=4.88u w=2u l=0.28u
X185 XFRONT.XFE_O.SB.t2 SAMP_O_N.t7 XFRONT.XFE_O.NTAIL.t8 VSS.t124 nfet_03v3 ad=3.52p pd=16.88u as=2.08p ps=8.52u w=8u l=0.28u
X186 XFRONT.XFE_E.NTAIL.t10 SAMP_E_N.t8 XFRONT.XFE_E.SA.t5 VSS.t492 nfet_03v3 ad=2.08p pd=8.52u as=3.52p ps=16.88u w=8u l=0.28u
X187 XFRONT.XFE_E.BP.t4 XFRONT.XFE_E.SXP.t16 VSS.t343 VSS.t342 nfet_03v3 ad=2.08p pd=8.52u as=2.08p ps=8.52u w=8u l=0.28u
X188 a_n852_28800.t1 a_600_22678.t4 RX_RESTN.t2 VSS.t209 nfet_03v3 ad=2.6p pd=10.52u as=4.4p ps=20.88u w=10u l=0.28u
X189 VDD.t352 XFRONT.XFE_O.SXN.t21 XFRONT.XFE_O.BN.t2 VDD.t351 pfet_03v3 ad=2.08p pd=8.52u as=3.52p ps=16.88u w=8u l=0.28u
X190 VDD.t285 XFRONT.XFE_E.BP.t17 FE_E_N.t5 VDD.t284 pfet_03v3 ad=2.08p pd=8.52u as=2.08p ps=8.52u w=8u l=0.28u
X191 VDD.t567 XCAP.E_QBBUF.t10 EVEN_Q.t6 VDD.t566 pfet_03v3 ad=2.08p pd=8.52u as=3.52p ps=16.88u w=8u l=0.28u
X192 XFRONT.XFE_E.XN.t7 E_REGEN_CLK.t34 VDD.t230 VDD.t229 pfet_03v3 ad=2.08p pd=8.52u as=2.08p ps=8.52u w=8u l=0.28u
X193 XFRONT.XFE_O.VREGP.t8 XFRONT.XFE_O.XN.t57 XFRONT.XFE_O.XP.t30 VDD.t407 pfet_03v3 ad=2.08p pd=8.52u as=3.52p ps=16.88u w=8u l=0.28u
X194 XCAP.E_PRST_TAIL.t9 E_CAPTURE_CLKB.t8 VDD.t316 VDD.t315 pfet_03v3 ad=3.52p pd=16.88u as=2.08p ps=8.52u w=8u l=0.28u
X195 VDD.t306 E_CAPTURE_CLKB.t15 XCAP.E_PRST_TAIL.t2 VDD.t304 pfet_03v3 ad=2.08p pd=8.52u as=3.52p ps=16.88u w=8u l=0.28u
X196 XCAP.O_QBBUF.t1 XCAP.O_QI.t18 VDD.t96 VDD.t95 pfet_03v3 ad=3.52p pd=16.88u as=2.08p ps=8.52u w=8u l=0.28u
X197 FE_O_N.t4 XFRONT.XFE_O.BN.t22 VDD.t358 VDD.t357 pfet_03v3 ad=2.08p pd=8.52u as=2.08p ps=8.52u w=8u l=0.28u
X198 XCAP.E_SET_TAIL.t9 E_CAPTURE_CLK.t8 VSS.t272 VSS.t271 nfet_03v3 ad=3.52p pd=16.88u as=2.08p ps=8.52u w=8u l=0.28u
X199 VSS.t101 O_CAPTURE_CLK.t11 XCAP.O_SET_TAIL.t8 VSS.t100 nfet_03v3 ad=2.08p pd=8.52u as=2.08p ps=8.52u w=8u l=0.28u
X200 VSS.t6 O_SENSE_BOOST.t1 XFRONT.XFE_O.NTAIL.t4 VSS.t5 nfet_03v3 ad=2.08p pd=8.52u as=2.08p ps=8.52u w=8u l=0.28u
X201 VSS.t203 XFRONT.XFE_E.BN.t11 FE_E_P.t3 VSS.t202 nfet_03v3 ad=2.08p pd=8.52u as=2.08p ps=8.52u w=8u l=0.28u
X202 XFRONT.XFE_E.VREGN.t5 E_REGEN_CLKB.t10 VDD.t61 VDD.t60 pfet_03v3 ad=2.08p pd=8.52u as=2.08p ps=8.52u w=8u l=0.28u
X203 XFRONT.XFE_O.VREGP.t1 O_REGEN_CLKB.t14 VDD.t430 VDD.t429 pfet_03v3 ad=2.08p pd=8.52u as=2.08p ps=8.52u w=8u l=0.28u
X204 VDD.t251 E_REGEN_CLK.t15 XFRONT.XFE_E.XP.t9 VDD.t80 pfet_03v3 ad=2.08p pd=8.52u as=2.08p ps=8.52u w=8u l=0.28u
X205 XFRONT.XFE_E.XP.t22 XFRONT.XFE_E.XN.t35 XFRONT.XFE_E.NREGEN.t28 VSS.t481 nfet_03v3 ad=3.52p pd=16.88u as=2.08p ps=8.52u w=8u l=0.28u
X206 XCAP.EVEN_D_BUF.t5 FE_E_N.t20 VDD.t335 VDD.t334 pfet_03v3 ad=2.08p pd=8.52u as=2.08p ps=8.52u w=8u l=0.28u
X207 VDD.t34 FE_E_P.t21 XCAP.EVEN_DB_BUF.t4 VDD.t33 pfet_03v3 ad=2.08p pd=8.52u as=2.08p ps=8.52u w=8u l=0.28u
X208 a_n852_19400.t7 RX_RAWN.t5 a_600_22678.t0 VSS.t209 nfet_03v3 ad=2.6p pd=10.52u as=4.4p ps=20.88u w=10u l=0.28u
X209 XFRONT.XFE_E.VREGN.t8 XFRONT.XFE_E.XP.t57 XFRONT.XFE_E.XN.t28 VDD.t376 pfet_03v3 ad=2.08p pd=8.52u as=3.52p ps=16.88u w=8u l=0.28u
X210 VDD.t116 FE_O_P.t23 XCAP.ODD_DB_BUF.t2 VDD.t115 pfet_03v3 ad=2.08p pd=8.52u as=2.08p ps=8.52u w=8u l=0.28u
X211 VSS.t305 O_SENSE_CLK.t1 XFRONT.XFE_O.NTAIL.t10 VSS.t304 nfet_03v3 ad=2.08p pd=8.52u as=3.52p ps=16.88u w=8u l=0.28u
X212 VSS.t407 XFRONT.XFE_E.SXN.t17 XFRONT.XFE_E.BN.t4 VSS.t406 nfet_03v3 ad=2.08p pd=8.52u as=2.08p ps=8.52u w=8u l=0.28u
X213 XCAP.O_RST_TAIL.t11 XCAP.ODD_DB_BUF.t15 XCAP.O_QI.t11 VSS.t96 nfet_03v3 ad=2.08p pd=8.52u as=3.52p ps=16.88u w=8u l=0.28u
X214 VSS.t219 O_REGEN_CLK.t5 XFRONT.XFE_O.NREGEN.t20 VSS.t9 nfet_03v3 ad=2.08p pd=8.52u as=2.08p ps=8.52u w=8u l=0.28u
X215 VDD.t173 O_REGEN_CLK.t35 XFRONT.XFE_O.XP.t6 VDD.t172 pfet_03v3 ad=2.08p pd=8.52u as=3.52p ps=16.88u w=8u l=0.28u
X216 a_n6400_n16252.t3 TERM_EN4_N.t0 a_n7300_n16300.t4 VDD.t464 pfet_03v3 ad=2.6p pd=10.52u as=4.4p ps=20.88u w=10u l=0.28u
X217 a_2548_44200.t3 SAMP_CLK_N.t2 a_2148_41600.t2 VSS.t439 nfet_03v3 ad=3.52p pd=16.88u as=2.08p ps=8.52u w=8u l=0.28u
X218 XCAP.O_QI.t5 XCAP.ODD_DB_BUF.t18 XCAP.O_PSET_TAIL.t2 VDD.t21 pfet_03v3 ad=2.08p pd=8.52u as=2.08p ps=8.52u w=8u l=0.28u
X219 VSS.t502 XCAP.E_QBUF.t6 EVEN_QB.t5 VSS.t501 nfet_03v3 ad=2.08p pd=8.52u as=3.52p ps=16.88u w=8u l=0.28u
X220 VDD.t529 O_CAPTURE_CLKB.t3 XCAP.O_PSET_TAIL.t8 VDD.t14 pfet_03v3 ad=2.08p pd=8.52u as=2.08p ps=8.52u w=8u l=0.28u
X221 a_n10800_n19772.t0 TERM_EN2_N.t3 VDD.t505 VDD.t504 pfet_03v3 ad=0.88p pd=4.88u as=0.88p ps=4.88u w=2u l=0.28u
X222 VDD.t130 XCAP.E_QBI.t17 XCAP.E_QI.t2 VDD.t129 pfet_03v3 ad=2.08p pd=8.52u as=3.52p ps=16.88u w=8u l=0.28u
X223 XFRONT.XFE_E.SXP.t5 XFRONT.XFE_E.XP.t38 VSS.t301 VSS.t300 nfet_03v3 ad=3.52p pd=16.88u as=2.08p ps=8.52u w=8u l=0.28u
X224 XCAP.E_QI.t6 XCAP.EVEN_DB_BUF.t16 XCAP.E_PSET_TAIL.t9 VDD.t6 pfet_03v3 ad=3.52p pd=16.88u as=2.08p ps=8.52u w=8u l=0.28u
X225 FE_E_P.t6 XFRONT.XFE_E.BN.t14 VSS.t295 VSS.t294 nfet_03v3 ad=2.08p pd=8.52u as=2.08p ps=8.52u w=8u l=0.28u
X226 a_11748_41600.t5 SAMP_BIAS.t2 VSS.t445 VSS.t444 nfet_03v3 ad=2.6p pd=10.52u as=2.6p ps=10.52u w=10u l=0.28u
X227 RXP.t1 a_n7300_n16300.t0 VSS.t2 ppolyf_u r_width=1u r_length=1u
X228 XCAP.E_PSET_TAIL.t5 E_CAPTURE_CLKB.t2 VDD.t319 VDD.t313 pfet_03v3 ad=2.08p pd=8.52u as=2.08p ps=8.52u w=8u l=0.28u
X229 VSS.t48 FE_E_P.t15 XCAP.EVEN_DB_BUF.t10 VSS.t47 nfet_03v3 ad=2.08p pd=8.52u as=2.08p ps=8.52u w=8u l=0.28u
X230 XFRONT.XFE_E.XN.t13 E_REGEN_CLK.t28 VDD.t236 VDD.t235 pfet_03v3 ad=3.52p pd=16.88u as=2.08p ps=8.52u w=8u l=0.28u
X231 XFRONT.XFE_O.NREGEN.t17 O_REGEN_CLK.t8 VDD.t211 VDD.t210 pfet_03v3 ad=3.52p pd=16.88u as=2.08p ps=8.52u w=8u l=0.28u
X232 XCAP.O_QI.t8 XCAP.ODD_DB_BUF.t12 XCAP.O_RST_TAIL.t8 VSS.t102 nfet_03v3 ad=3.52p pd=16.88u as=2.08p ps=8.52u w=8u l=0.28u
X233 FE_O_N.t12 XFRONT.XFE_O.BN.t14 VSS.t361 VSS.t360 nfet_03v3 ad=2.08p pd=8.52u as=2.08p ps=8.52u w=8u l=0.28u
X234 XFRONT.XFE_O.NREGEN.t1 XFRONT.XFE_O.SA.t8 XFRONT.XFE_O.XN.t0 VSS.t34 nfet_03v3 ad=2.08p pd=8.52u as=2.08p ps=8.52u w=8u l=0.28u
X235 XFRONT.XFE_O.NREGEN.t23 O_REGEN_CLK.t2 VSS.t222 VSS.t5 nfet_03v3 ad=2.08p pd=8.52u as=2.08p ps=8.52u w=8u l=0.28u
X236 VDD.t520 O_CAPTURE_CLKB.t13 XCAP.O_PRST_TAIL.t6 VDD.t519 pfet_03v3 ad=2.08p pd=8.52u as=2.08p ps=8.52u w=8u l=0.28u
X237 XFRONT.XFE_O.NREGEN.t11 XFRONT.XFE_O.XN.t37 XFRONT.XFE_O.XP.t24 VSS.t166 nfet_03v3 ad=2.08p pd=8.52u as=3.52p ps=16.88u w=8u l=0.28u
X238 VSS.t389 XFRONT.XFE_O.BP.t15 FE_O_P.t10 VSS.t388 nfet_03v3 ad=2.08p pd=8.52u as=3.52p ps=16.88u w=8u l=0.28u
X239 a_n5052_2600.t3 RX_BIAS.t10 VSS.t78 VSS.t76 nfet_03v3 ad=0.88p pd=4.88u as=0.52p ps=2.52u w=2u l=0.28u
X240 a_n6572_3500.t1 RXP.t8 a_n5052_n1000.t1 VSS.t61 nfet_03v3 ad=4.4p pd=20.88u as=2.6p ps=10.52u w=10u l=0.28u
X241 a_n6400_n19852.t4 TERM_EN2_N.t0 a_n7300_n19900.t4 VDD.t507 pfet_03v3 ad=2.6p pd=10.52u as=4.4p ps=20.88u w=10u l=0.28u
X242 a_n3600_5641.t3 VTHN.t0 a_n5052_2600.t7 VSS.t215 nfet_03v3 ad=0.88p pd=4.88u as=0.52p ps=2.52u w=2u l=0.28u
X243 XFRONT.XFE_E.SB.t6 SAMP_E_P.t7 XFRONT.XFE_E.NTAIL.t2 VSS.t140 nfet_03v3 ad=3.52p pd=16.88u as=2.08p ps=8.52u w=8u l=0.28u
X244 XFRONT.XFE_O.NREGEN.t31 XFRONT.XFE_O.XP.t35 XFRONT.XFE_O.XN.t32 VSS.t498 nfet_03v3 ad=3.52p pd=16.88u as=2.08p ps=8.52u w=8u l=0.28u
X245 XFRONT.XFE_E.XP.t1 XFRONT.XFE_E.SB.t9 XFRONT.XFE_E.NREGEN.t2 VSS.t17 nfet_03v3 ad=2.08p pd=8.52u as=2.08p ps=8.52u w=8u l=0.28u
X246 XFRONT.XFE_E.SXP.t0 XFRONT.XFE_E.XP.t48 VDD.t267 VDD.t266 pfet_03v3 ad=2.08p pd=8.52u as=2.08p ps=8.52u w=8u l=0.28u
X247 XCAP.EVEN_D_BUF.t3 FE_E_N.t22 VDD.t329 VDD.t328 pfet_03v3 ad=2.08p pd=8.52u as=2.08p ps=8.52u w=8u l=0.28u
X248 VSS.t33 XCAP.O_QBBUF.t4 ODD_Q.t0 VSS.t32 nfet_03v3 ad=3.52p pd=16.88u as=2.08p ps=8.52u w=8u l=0.28u
X249 VDD.t394 XFRONT.XFE_E.SXP.t21 XFRONT.XFE_E.BP.t9 VDD.t393 pfet_03v3 ad=2.08p pd=8.52u as=3.52p ps=16.88u w=8u l=0.28u
X250 VDD.t234 E_REGEN_CLK.t31 XFRONT.XFE_E.XN.t10 VDD.t82 pfet_03v3 ad=2.08p pd=8.52u as=2.08p ps=8.52u w=8u l=0.28u
X251 a_n7157_n23500.t3 TERM_EN0_N.t1 a_n6400_n23452.t2 VDD.t347 pfet_03v3 ad=4.4p pd=20.88u as=2.6p ps=10.52u w=10u l=0.28u
X252 RXP.t0 a_n7300_n19900.t0 VSS.t2 ppolyf_u r_width=1u r_length=1u
X253 VSS.t233 E_SENSE_BOOST.t3 XFRONT.XFE_E.NTAIL.t6 VSS.t232 nfet_03v3 ad=2.08p pd=8.52u as=2.08p ps=8.52u w=8u l=0.28u
X254 XFRONT.XFE_E.SA.t2 E_SENSE_CLK.t2 VDD.t81 VDD.t80 pfet_03v3 ad=3.52p pd=16.88u as=2.08p ps=8.52u w=8u l=0.28u
X255 XFRONT.XFE_O.VREGN.t0 XFRONT.XFE_O.XP.t57 XFRONT.XFE_O.XN.t31 VDD.t547 pfet_03v3 ad=2.08p pd=8.52u as=3.52p ps=16.88u w=8u l=0.28u
X256 XFRONT.XFE_O.XP.t19 O_REGEN_CLK.t22 XFRONT.XFE_O.XN.t20 VDD.t189 pfet_03v3 ad=2.08p pd=8.52u as=2.08p ps=8.52u w=8u l=0.28u
X257 a_11748_41600.t3 SAMP_CLK_N.t1 a_10548_44200.t4 VSS.t440 nfet_03v3 ad=2.08p pd=8.52u as=3.52p ps=16.88u w=8u l=0.28u
X258 FE_O_P.t7 XFRONT.XFE_O.BP.t12 VSS.t289 VSS.t288 nfet_03v3 ad=2.08p pd=8.52u as=2.08p ps=8.52u w=8u l=0.28u
X259 VDD.t107 RX_RAWN.t0 VSS.t173 ppolyf_u r_width=2u r_length=3.43u
X260 VSS.t430 REST_BIAS.t3 a_n852_19400.t2 VSS.t421 nfet_03v3 ad=3.12p pd=12.52u as=5.28p ps=24.88u w=12u l=0.28u
X261 a_n7300_n14500.t3 a_n10800_n14372.t3 a_n6400_n14452.t4 VSS.t321 nfet_03v3 ad=4.4p pd=20.88u as=2.6p ps=10.52u w=10u l=0.28u
X262 VSS.t214 XFRONT.XFE_E.BP.t15 FE_E_N.t3 VSS.t213 nfet_03v3 ad=2.08p pd=8.52u as=3.52p ps=16.88u w=8u l=0.28u
X263 XCAP.O_PSET_TAIL.t11 O_CAPTURE_CLKB.t0 VDD.t513 VDD.t512 pfet_03v3 ad=3.52p pd=16.88u as=2.08p ps=8.52u w=8u l=0.28u
X264 VDD.t516 O_CAPTURE_CLKB.t7 XCAP.O_PSET_TAIL.t4 VDD.t514 pfet_03v3 ad=2.08p pd=8.52u as=3.52p ps=16.88u w=8u l=0.28u
X265 a_n10800_n12572.t1 TERM_EN6_N.t2 VSS.t240 VSS.t226 nfet_03v3 ad=0.44p pd=2.88u as=0.44p ps=2.88u w=1u l=0.28u
X266 XFRONT.XFE_O.XN.t12 O_REGEN_CLK.t16 VDD.t199 VDD.t198 pfet_03v3 ad=2.08p pd=8.52u as=2.08p ps=8.52u w=8u l=0.28u
X267 VDD.t169 O_REGEN_CLK.t11 XFRONT.XFE_O.NREGEN.t14 VDD.t168 pfet_03v3 ad=2.08p pd=8.52u as=3.52p ps=16.88u w=8u l=0.28u
X268 XFRONT.XFE_E.NREGEN.t33 XFRONT.XFE_E.SB.t12 XFRONT.XFE_E.XP.t32 VSS.t508 nfet_03v3 ad=2.08p pd=8.52u as=2.08p ps=8.52u w=8u l=0.28u
X269 XFRONT.XFE_E.BN.t7 XFRONT.XFE_E.SXN.t14 VSS.t415 VSS.t414 nfet_03v3 ad=2.08p pd=8.52u as=2.08p ps=8.52u w=8u l=0.28u
X270 VSS.t85 RX_BIAS.t0 a_2148_n500.t4 VSS.t71 nfet_03v3 ad=4.4p pd=20.88u as=2.6p ps=10.52u w=10u l=0.28u
X271 VDD.t477 FE_O_N.t21 XCAP.ODD_D_BUF.t4 VDD.t95 pfet_03v3 ad=2.08p pd=8.52u as=2.08p ps=8.52u w=8u l=0.28u
X272 a_n10800_n21572.t0 TERM_EN1_N.t3 VDD.t501 VDD.t500 pfet_03v3 ad=0.88p pd=4.88u as=0.88p ps=4.88u w=2u l=0.28u
X273 VSS.t435 XCAP.O_QBI.t13 XCAP.O_QI.t7 VSS.t98 nfet_03v3 ad=2.08p pd=8.52u as=3.52p ps=16.88u w=8u l=0.28u
X274 XFRONT.XFE_O.SXN.t7 XFRONT.XFE_O.XN.t46 VDD.t483 VDD.t482 pfet_03v3 ad=2.08p pd=8.52u as=2.08p ps=8.52u w=8u l=0.28u
X275 XCAP.E_QBBUF.t3 XCAP.E_QI.t14 VSS.t483 VSS.t314 nfet_03v3 ad=1.76p pd=8.88u as=1.04p ps=4.52u w=4u l=0.28u
X276 VDD.t59 E_REGEN_CLKB.t11 XFRONT.XFE_E.VREGN.t4 VDD.t58 pfet_03v3 ad=2.08p pd=8.52u as=2.08p ps=8.52u w=8u l=0.28u
X277 XFRONT.XFE_E.VREGP.t10 XFRONT.XFE_E.XN.t55 XFRONT.XFE_E.XP.t34 VDD.t571 pfet_03v3 ad=2.08p pd=8.52u as=2.08p ps=8.52u w=8u l=0.28u
X278 VSS.t77 RX_BIAS.t11 a_n5052_2600.t2 VSS.t76 nfet_03v3 ad=0.52p pd=2.52u as=0.52p ps=2.52u w=2u l=0.28u
X279 a_n5052_n1000.t0 RXP.t9 a_n6572_3500.t0 VSS.t61 nfet_03v3 ad=2.6p pd=10.52u as=4.4p ps=20.88u w=10u l=0.28u
X280 VSS.t42 XCAP.O_QI.t15 XCAP.O_QBBUF.t2 VSS.t41 nfet_03v3 ad=1.04p pd=4.52u as=1.76p ps=8.88u w=4u l=0.28u
X281 VSS.t160 XCAP.E_QBI.t13 XCAP.E_QI.t0 VSS.t159 nfet_03v3 ad=2.08p pd=8.52u as=3.52p ps=16.88u w=8u l=0.28u
X282 VSS.t422 REST_BIAS.t7 a_n852_28800.t4 VSS.t421 nfet_03v3 ad=3.12p pd=12.52u as=5.28p ps=24.88u w=12u l=0.28u
X283 XFRONT.XFE_E.BP.t6 XFRONT.XFE_E.SXP.t18 VSS.t391 VSS.t390 nfet_03v3 ad=2.08p pd=8.52u as=2.08p ps=8.52u w=8u l=0.28u
X284 XCAP.O_QBUF.t1 XCAP.O_QBI.t18 VDD.t24 VDD.t23 pfet_03v3 ad=3.52p pd=16.88u as=2.08p ps=8.52u w=8u l=0.28u
X285 FE_E_N.t0 XFRONT.XFE_E.BP.t12 VSS.t208 VSS.t62 nfet_03v3 ad=2.08p pd=8.52u as=2.08p ps=8.52u w=8u l=0.28u
X286 VDD.t448 O_REGEN_CLKB.t7 XFRONT.XFE_O.VREGN.t8 VDD.t447 pfet_03v3 ad=2.08p pd=8.52u as=3.52p ps=16.88u w=8u l=0.28u
X287 XFRONT.XFE_E.NREGEN.t18 E_REGEN_CLK.t4 VSS.t242 VSS.t232 nfet_03v3 ad=2.08p pd=8.52u as=2.08p ps=8.52u w=8u l=0.28u
X288 XCAP.E_SET_TAIL.t7 E_CAPTURE_CLK.t10 VSS.t268 VSS.t267 nfet_03v3 ad=2.08p pd=8.52u as=2.08p ps=8.52u w=8u l=0.28u
X289 XCAP.E_QBI.t4 XCAP.EVEN_D_BUF.t18 XCAP.E_PRST_TAIL.t10 VDD.t129 pfet_03v3 ad=2.08p pd=8.52u as=2.08p ps=8.52u w=8u l=0.28u
X290 VDD.t22 XCAP.O_QBI.t17 XCAP.O_QI.t1 VDD.t21 pfet_03v3 ad=2.08p pd=8.52u as=3.52p ps=16.88u w=8u l=0.28u
X291 VDD.t203 O_REGEN_CLK.t13 XFRONT.XFE_O.XN.t15 VDD.t202 pfet_03v3 ad=2.08p pd=8.52u as=2.08p ps=8.52u w=8u l=0.28u
X292 FE_O_N.t2 XFRONT.XFE_O.BN.t20 VDD.t354 VDD.t353 pfet_03v3 ad=2.08p pd=8.52u as=2.08p ps=8.52u w=8u l=0.28u
X293 XCAP.O_QBI.t9 XCAP.O_QI.t16 VDD.t15 VDD.t14 pfet_03v3 ad=3.52p pd=16.88u as=2.08p ps=8.52u w=8u l=0.28u
X294 XFRONT.XFE_O.XN.t25 XFRONT.XFE_O.SA.t11 XFRONT.XFE_O.NREGEN.t26 VSS.t302 nfet_03v3 ad=2.08p pd=8.52u as=2.08p ps=8.52u w=8u l=0.28u
X295 a_n7300_n18100.t2 a_n10800_n17972.t3 a_n6400_n18052.t3 VSS.t316 nfet_03v3 ad=4.4p pd=20.88u as=2.6p ps=10.52u w=10u l=0.28u
X296 VDD.t248 E_REGEN_CLK.t17 XFRONT.XFE_E.XP.t7 VDD.t247 pfet_03v3 ad=2.08p pd=8.52u as=2.08p ps=8.52u w=8u l=0.28u
X297 VSS.t449 SAMP_BIAS.t7 a_2148_41600.t4 VSS.t448 nfet_03v3 ad=2.6p pd=10.52u as=4.4p ps=20.88u w=10u l=0.28u
X298 VDD.t422 XFRONT.XFE_O.XN.t43 XFRONT.XFE_O.SXN.t4 VDD.t421 pfet_03v3 ad=2.08p pd=8.52u as=2.08p ps=8.52u w=8u l=0.28u
X299 VDD.t263 XCAP.O_QBUF.t8 ODD_QB.t4 VDD.t262 pfet_03v3 ad=2.08p pd=8.52u as=2.08p ps=8.52u w=8u l=0.28u
X300 XFRONT.XFE_E.VREGN.t1 E_REGEN_CLKB.t14 VDD.t57 VDD.t56 pfet_03v3 ad=2.08p pd=8.52u as=2.08p ps=8.52u w=8u l=0.28u
X301 a_n6400_n21652.t3 TERM_EN1_N.t0 a_n7157_n21700.t4 VDD.t503 pfet_03v3 ad=2.6p pd=10.52u as=4.4p ps=20.88u w=10u l=0.28u
X302 a_n6400_n21652.t0 RXN.t5 VSS.t255 ppolyf_u r_width=1u r_length=2.43u
X303 VDD.t155 XFRONT.XFE_O.BP.t23 FE_O_P.t4 VDD.t154 pfet_03v3 ad=2.08p pd=8.52u as=3.52p ps=16.88u w=8u l=0.28u
X304 VDD.t167 O_REGEN_CLK.t33 XFRONT.XFE_O.XP.t8 VDD.t166 pfet_03v3 ad=2.08p pd=8.52u as=2.08p ps=8.52u w=8u l=0.28u
X305 a_948_44200.t0 RX_RESTP.t6 SAMP_E_N.t3 VSS.t64 nfet_03v3 ad=1.56p pd=6.52u as=2.64p ps=12.88u w=6u l=0.28u
X306 XFRONT.XFE_E.SB.t2 E_SENSE_CLK.t6 VDD.t83 VDD.t82 pfet_03v3 ad=3.52p pd=16.88u as=2.08p ps=8.52u w=8u l=0.28u
X307 XFRONT.XFE_O.XP.t32 XFRONT.XFE_O.XN.t52 XFRONT.XFE_O.VREGP.t13 VDD.t412 pfet_03v3 ad=2.08p pd=8.52u as=2.08p ps=8.52u w=8u l=0.28u
X308 a_n6400_n12652.t4 a_n10800_n12572.t2 a_n7300_n12700.t4 VSS.t485 nfet_03v3 ad=2.6p pd=10.52u as=4.4p ps=20.88u w=10u l=0.28u
X309 VDD.t45 XCAP.E_QBUF.t8 EVEN_QB.t4 VDD.t44 pfet_03v3 ad=2.08p pd=8.52u as=2.08p ps=8.52u w=8u l=0.28u
X310 a_948_44200.t2 RX_RESTN.t6 SAMP_E_P.t0 VSS.t135 nfet_03v3 ad=1.56p pd=6.52u as=2.64p ps=12.88u w=6u l=0.28u
X311 VDD.t364 XFRONT.XFE_O.BN.t17 FE_O_N.t7 VDD.t363 pfet_03v3 ad=2.08p pd=8.52u as=2.08p ps=8.52u w=8u l=0.28u
X312 XFRONT.XFE_E.NTAIL.t9 E_SENSE_BOOST.t0 VSS.t239 VSS.t238 nfet_03v3 ad=3.52p pd=16.88u as=2.08p ps=8.52u w=8u l=0.28u
X313 VDD.t111 XFRONT.XFE_O.XP.t49 XFRONT.XFE_O.SXP.t3 VDD.t110 pfet_03v3 ad=2.08p pd=8.52u as=3.52p ps=16.88u w=8u l=0.28u
X314 VDD.t444 O_REGEN_CLKB.t9 XFRONT.XFE_O.VREGP.t6 VDD.t443 pfet_03v3 ad=2.08p pd=8.52u as=2.08p ps=8.52u w=8u l=0.28u
X315 XFRONT.XFE_O.XN.t17 O_REGEN_CLK.t25 XFRONT.XFE_O.XP.t16 VDD.t186 pfet_03v3 ad=2.08p pd=8.52u as=2.08p ps=8.52u w=8u l=0.28u
X316 EVEN_Q.t1 XCAP.E_QBBUF.t5 VSS.t36 VSS.t35 nfet_03v3 ad=2.08p pd=8.52u as=2.08p ps=8.52u w=8u l=0.28u
X317 a_2148_41600.t7 SAMP_BIAS.t4 VSS.t455 VSS.t454 nfet_03v3 ad=4.4p pd=20.88u as=2.6p ps=10.52u w=10u l=0.28u
X318 XFRONT.XFE_E.BP.t0 XFRONT.XFE_E.SXP.t12 VSS.t325 VSS.t324 nfet_03v3 ad=3.52p pd=16.88u as=2.08p ps=8.52u w=8u l=0.28u
X319 a_12148_44200.t0 SAMP_O_P.t6 SAMP_O_N.t3 VSS.t121 nfet_03v3 ad=1.56p pd=6.52u as=2.64p ps=12.88u w=6u l=0.28u
X320 FE_E_N.t12 XFRONT.XFE_E.BP.t10 VSS.t504 VSS.t503 nfet_03v3 ad=3.52p pd=16.88u as=2.08p ps=8.52u w=8u l=0.28u
X321 VDD.t294 O_SENSE_CLK.t3 XFRONT.XFE_O.SB.t3 VDD.t198 pfet_03v3 ad=2.08p pd=8.52u as=3.52p ps=16.88u w=8u l=0.28u
X322 XCAP.ODD_D_BUF.t7 FE_O_N.t18 VDD.t479 VDD.t478 pfet_03v3 ad=3.52p pd=16.88u as=2.08p ps=8.52u w=8u l=0.28u
X323 FE_O_N.t10 XFRONT.XFE_O.BN.t12 VSS.t357 VSS.t356 nfet_03v3 ad=2.08p pd=8.52u as=2.08p ps=8.52u w=8u l=0.28u
X324 VDD.t467 FE_O_N.t25 XCAP.ODD_D_BUF.t0 VDD.t466 pfet_03v3 ad=2.08p pd=8.52u as=3.52p ps=16.88u w=8u l=0.28u
X325 XFRONT.XFE_O.NREGEN.t25 O_REGEN_CLK.t0 VSS.t225 VSS.t224 nfet_03v3 ad=3.52p pd=16.88u as=2.08p ps=8.52u w=8u l=0.28u
X326 XFRONT.XFE_O.XP.t11 O_REGEN_CLK.t30 VDD.t179 VDD.t178 pfet_03v3 ad=2.08p pd=8.52u as=2.08p ps=8.52u w=8u l=0.28u
X327 VSS.t4 O_SENSE_BOOST.t5 XFRONT.XFE_O.NTAIL.t0 VSS.t3 nfet_03v3 ad=2.08p pd=8.52u as=3.52p ps=16.88u w=8u l=0.28u
X328 XFRONT.XFE_E.NREGEN.t7 XFRONT.XFE_E.SA.t8 XFRONT.XFE_E.XN.t4 VSS.t164 nfet_03v3 ad=2.08p pd=8.52u as=2.08p ps=8.52u w=8u l=0.28u
X329 XFRONT.XFE_O.SXN.t10 XFRONT.XFE_O.XN.t40 VSS.t471 VSS.t470 nfet_03v3 ad=2.08p pd=8.52u as=2.08p ps=8.52u w=8u l=0.28u
X330 a_n10800_n16172.t1 TERM_EN4_N.t2 VSS.t433 VSS.t226 nfet_03v3 ad=0.44p pd=2.88u as=0.44p ps=2.88u w=1u l=0.28u
X331 VSS.t461 FE_O_N.t17 XCAP.ODD_D_BUF.t8 VSS.t460 nfet_03v3 ad=2.08p pd=8.52u as=3.52p ps=16.88u w=8u l=0.28u
X332 VDD.t124 FE_O_P.t21 XCAP.ODD_DB_BUF.t4 VDD.t123 pfet_03v3 ad=2.08p pd=8.52u as=2.08p ps=8.52u w=8u l=0.28u
X333 XFRONT.XFE_E.XP.t27 XFRONT.XFE_E.XN.t52 XFRONT.XFE_E.VREGP.t13 VDD.t534 pfet_03v3 ad=2.08p pd=8.52u as=2.08p ps=8.52u w=8u l=0.28u
X334 SAMP_E_P.t3 SAMP_E_N.t5 a_2548_44200.t5 VSS.t495 nfet_03v3 ad=2.64p pd=12.88u as=1.56p ps=6.52u w=6u l=0.28u
X335 XFRONT.XFE_O.NTAIL.t9 SAMP_O_N.t8 XFRONT.XFE_O.SB.t1 VSS.t123 nfet_03v3 ad=2.08p pd=8.52u as=3.52p ps=16.88u w=8u l=0.28u
X336 VSS.t379 XFRONT.XFE_O.SXP.t19 XFRONT.XFE_O.BP.t2 VSS.t378 nfet_03v3 ad=2.08p pd=8.52u as=3.52p ps=16.88u w=8u l=0.28u
X337 XCAP.E_QBUF.t2 XCAP.E_QBI.t18 VDD.t132 VDD.t131 pfet_03v3 ad=3.52p pd=16.88u as=2.08p ps=8.52u w=8u l=0.28u
X338 XFRONT.XFE_E.SA.t6 SAMP_E_N.t7 XFRONT.XFE_E.NTAIL.t11 VSS.t493 nfet_03v3 ad=3.52p pd=16.88u as=2.08p ps=8.52u w=8u l=0.28u
X339 XCAP.ODD_DB_BUF.t11 FE_O_P.t14 VSS.t189 VSS.t188 nfet_03v3 ad=3.52p pd=16.88u as=2.08p ps=8.52u w=8u l=0.28u
X340 XCAP.O_QBI.t0 XCAP.ODD_D_BUF.t12 XCAP.O_SET_TAIL.t0 VSS.t0 nfet_03v3 ad=3.52p pd=16.88u as=2.08p ps=8.52u w=8u l=0.28u
X341 VSS.t341 XFRONT.XFE_E.SXP.t15 XFRONT.XFE_E.BP.t3 VSS.t340 nfet_03v3 ad=2.08p pd=8.52u as=2.08p ps=8.52u w=8u l=0.28u
X342 VDD.t232 E_REGEN_CLK.t33 XFRONT.XFE_E.XN.t8 VDD.t231 pfet_03v3 ad=2.08p pd=8.52u as=2.08p ps=8.52u w=8u l=0.28u
X343 VSS.t248 E_REGEN_CLK.t1 XFRONT.XFE_E.NREGEN.t21 VSS.t238 nfet_03v3 ad=2.08p pd=8.52u as=2.08p ps=8.52u w=8u l=0.28u
X344 VSS.t270 E_CAPTURE_CLK.t9 XCAP.E_SET_TAIL.t8 VSS.t269 nfet_03v3 ad=2.08p pd=8.52u as=2.08p ps=8.52u w=8u l=0.28u
X345 SAMP_O_P.t3 RX_RESTN.t3 a_10548_44200.t3 VSS.t138 nfet_03v3 ad=2.64p pd=12.88u as=1.56p ps=6.52u w=6u l=0.28u
X346 XCAP.O_SET_TAIL.t7 O_CAPTURE_CLK.t12 VSS.t99 VSS.t98 nfet_03v3 ad=2.08p pd=8.52u as=2.08p ps=8.52u w=8u l=0.28u
X347 XFRONT.XFE_E.SA.t0 VSS.t511 VDD.t161 VDD.t160 pfet_03v3 ad=3.52p pd=16.88u as=3.52p ps=16.88u w=8u l=0.28u
X348 XFRONT.XFE_O.VREGN.t2 XFRONT.XFE_O.XP.t55 XFRONT.XFE_O.XN.t8 VDD.t134 pfet_03v3 ad=2.08p pd=8.52u as=2.08p ps=8.52u w=8u l=0.28u
X349 FE_E_P.t12 XFRONT.XFE_E.BN.t20 VDD.t404 VDD.t403 pfet_03v3 ad=2.08p pd=8.52u as=2.08p ps=8.52u w=8u l=0.28u
X350 XFRONT.XFE_O.NTAIL.t3 O_SENSE_BOOST.t2 VSS.t8 VSS.t7 nfet_03v3 ad=2.08p pd=8.52u as=2.08p ps=8.52u w=8u l=0.28u
X351 VSS.t354 XFRONT.XFE_O.SXN.t19 XFRONT.XFE_O.BN.t0 VSS.t353 nfet_03v3 ad=2.08p pd=8.52u as=3.52p ps=16.88u w=8u l=0.28u
X352 XFRONT.XFE_E.XN.t5 XFRONT.XFE_E.SA.t11 XFRONT.XFE_E.NREGEN.t10 VSS.t179 nfet_03v3 ad=2.08p pd=8.52u as=2.08p ps=8.52u w=8u l=0.28u
X353 XFRONT.XFE_E.XP.t10 E_REGEN_CLK.t14 VDD.t250 VDD.t249 pfet_03v3 ad=2.08p pd=8.52u as=2.08p ps=8.52u w=8u l=0.28u
X354 a_2148_n500.t7 a_n3600_5641.t7 RX_RAWN.t2 VSS.t158 nfet_03v3 ad=1.3p pd=5.52u as=2.2p ps=10.88u w=5u l=0.28u
X355 XCAP.ODD_D_BUF.t11 FE_O_N.t14 VSS.t465 VSS.t464 nfet_03v3 ad=3.52p pd=16.88u as=2.08p ps=8.52u w=8u l=0.28u
X356 XCAP.E_QBBUF.t1 XCAP.E_QI.t18 VDD.t498 VDD.t332 pfet_03v3 ad=3.52p pd=16.88u as=2.08p ps=8.52u w=8u l=0.28u
X357 XCAP.E_SET_TAIL.t5 E_CAPTURE_CLK.t12 VSS.t266 VSS.t159 nfet_03v3 ad=2.08p pd=8.52u as=2.08p ps=8.52u w=8u l=0.28u
X358 XCAP.E_PSET_TAIL.t1 E_CAPTURE_CLKB.t6 VDD.t317 VDD.t298 pfet_03v3 ad=2.08p pd=8.52u as=2.08p ps=8.52u w=8u l=0.28u
X359 VDD.t522 O_CAPTURE_CLKB.t11 XCAP.O_PRST_TAIL.t8 VDD.t14 pfet_03v3 ad=2.08p pd=8.52u as=2.08p ps=8.52u w=8u l=0.28u
X360 XCAP.O_QBI.t4 XCAP.ODD_D_BUF.t18 XCAP.O_PRST_TAIL.t0 VDD.t21 pfet_03v3 ad=2.08p pd=8.52u as=2.08p ps=8.52u w=8u l=0.28u
X361 a_n10800_n19772.t1 TERM_EN2_N.t2 VSS.t491 VSS.t226 nfet_03v3 ad=0.44p pd=2.88u as=0.44p ps=2.88u w=1u l=0.28u
X362 XFRONT.XFE_O.NREGEN.t19 O_REGEN_CLK.t6 VSS.t218 VSS.t3 nfet_03v3 ad=2.08p pd=8.52u as=2.08p ps=8.52u w=8u l=0.28u
X363 a_2148_41600.t3 SAMP_CLK_N.t3 a_2548_44200.t2 VSS.t438 nfet_03v3 ad=2.08p pd=8.52u as=3.52p ps=16.88u w=8u l=0.28u
X364 XCAP.E_QBI.t0 XCAP.EVEN_D_BUF.t16 XCAP.E_PRST_TAIL.t0 VDD.t6 pfet_03v3 ad=3.52p pd=16.88u as=2.08p ps=8.52u w=8u l=0.28u
X365 XFRONT.XFE_O.VREGP.t10 XFRONT.XFE_O.XN.t55 XFRONT.XFE_O.XP.t27 VDD.t409 pfet_03v3 ad=2.08p pd=8.52u as=2.08p ps=8.52u w=8u l=0.28u
X366 VDD.t5 XCAP.E_QBBUF.t8 EVEN_Q.t0 VDD.t4 pfet_03v3 ad=2.08p pd=8.52u as=2.08p ps=8.52u w=8u l=0.28u
X367 VSS.t105 O_CAPTURE_CLK.t9 XCAP.O_SET_TAIL.t10 VSS.t104 nfet_03v3 ad=2.08p pd=8.52u as=2.08p ps=8.52u w=8u l=0.28u
X368 XFRONT.XFE_O.XN.t28 XFRONT.XFE_O.XP.t52 XFRONT.XFE_O.VREGN.t5 VDD.t486 pfet_03v3 ad=2.08p pd=8.52u as=2.08p ps=8.52u w=8u l=0.28u
X369 XFRONT.XFE_E.XN.t20 E_REGEN_CLK.t21 XFRONT.XFE_E.XP.t20 VDD.t241 pfet_03v3 ad=2.08p pd=8.52u as=2.08p ps=8.52u w=8u l=0.28u
X370 XCAP.E_PRST_TAIL.t7 E_CAPTURE_CLKB.t10 VDD.t314 VDD.t313 pfet_03v3 ad=2.08p pd=8.52u as=2.08p ps=8.52u w=8u l=0.28u
X371 a_n6400_n16252.t1 a_n10800_n16172.t2 a_n7300_n16300.t1 VSS.t317 nfet_03v3 ad=2.6p pd=10.52u as=4.4p ps=20.88u w=10u l=0.28u
X372 XFRONT.XFE_O.VREGP.t3 O_REGEN_CLKB.t12 VDD.t436 VDD.t435 pfet_03v3 ad=2.08p pd=8.52u as=2.08p ps=8.52u w=8u l=0.28u
X373 XFRONT.XFE_E.XP.t24 XFRONT.XFE_E.XN.t37 XFRONT.XFE_E.NREGEN.t30 VSS.t487 nfet_03v3 ad=2.08p pd=8.52u as=3.52p ps=16.88u w=8u l=0.28u
X374 XCAP.EVEN_DB_BUF.t11 FE_E_P.t14 VSS.t54 VSS.t53 nfet_03v3 ad=3.52p pd=16.88u as=2.08p ps=8.52u w=8u l=0.28u
X375 VDD.t209 O_REGEN_CLK.t9 XFRONT.XFE_O.NREGEN.t16 VDD.t208 pfet_03v3 ad=2.08p pd=8.52u as=3.52p ps=16.88u w=8u l=0.28u
X376 XFRONT.XFE_E.NREGEN.t23 XFRONT.XFE_E.XP.t36 XFRONT.XFE_E.XN.t31 VSS.t298 nfet_03v3 ad=2.08p pd=8.52u as=2.08p ps=8.52u w=8u l=0.28u
X377 VSS.t401 XFRONT.XFE_E.SXN.t19 XFRONT.XFE_E.BN.t2 VSS.t400 nfet_03v3 ad=2.08p pd=8.52u as=3.52p ps=16.88u w=8u l=0.28u
X378 VDD.t325 FE_E_N.t25 XCAP.EVEN_D_BUF.t0 VDD.t324 pfet_03v3 ad=2.08p pd=8.52u as=3.52p ps=16.88u w=8u l=0.28u
X379 XCAP.EVEN_D_BUF.t7 FE_E_N.t18 VDD.t337 VDD.t336 pfet_03v3 ad=3.52p pd=16.88u as=2.08p ps=8.52u w=8u l=0.28u
X380 XCAP.O_RST_TAIL.t9 XCAP.ODD_DB_BUF.t13 XCAP.O_QI.t9 VSS.t100 nfet_03v3 ad=2.08p pd=8.52u as=2.08p ps=8.52u w=8u l=0.28u
X381 VSS.t363 XFRONT.XFE_O.BN.t15 FE_O_N.t13 VSS.t362 nfet_03v3 ad=2.08p pd=8.52u as=3.52p ps=16.88u w=8u l=0.28u
X382 VDD.t38 FE_E_P.t19 XCAP.EVEN_DB_BUF.t6 VDD.t37 pfet_03v3 ad=2.08p pd=8.52u as=2.08p ps=8.52u w=8u l=0.28u
X383 VSS.t221 O_REGEN_CLK.t3 XFRONT.XFE_O.NREGEN.t22 VSS.t7 nfet_03v3 ad=2.08p pd=8.52u as=2.08p ps=8.52u w=8u l=0.28u
X384 VDD.t114 FE_O_P.t25 XCAP.ODD_DB_BUF.t0 VDD.t113 pfet_03v3 ad=2.08p pd=8.52u as=3.52p ps=16.88u w=8u l=0.28u
X385 XCAP.ODD_DB_BUF.t7 FE_O_P.t18 VDD.t128 VDD.t127 pfet_03v3 ad=3.52p pd=16.88u as=2.08p ps=8.52u w=8u l=0.28u
X386 VSS.t45 XCAP.E_QBUF.t4 EVEN_QB.t2 VSS.t44 nfet_03v3 ad=3.52p pd=16.88u as=2.08p ps=8.52u w=8u l=0.28u
X387 ODD_Q.t6 XCAP.O_QBBUF.t9 VDD.t341 VDD.t340 pfet_03v3 ad=2.08p pd=8.52u as=2.08p ps=8.52u w=8u l=0.28u
X388 RXP.t5 a_n7157_n21700.t0 VSS.t2 ppolyf_u r_width=1u r_length=2.43u
X389 VDD.t495 XFRONT.XFE_E.XN.t43 XFRONT.XFE_E.SXN.t6 VDD.t494 pfet_03v3 ad=2.08p pd=8.52u as=2.08p ps=8.52u w=8u l=0.28u
X390 XCAP.E_QBUF.t1 XCAP.E_QBI.t14 VSS.t162 VSS.t161 nfet_03v3 ad=1.76p pd=8.88u as=1.04p ps=4.52u w=4u l=0.28u
X391 XCAP.E_QBI.t10 XCAP.EVEN_D_BUF.t12 XCAP.E_SET_TAIL.t10 VSS.t279 nfet_03v3 ad=3.52p pd=16.88u as=2.08p ps=8.52u w=8u l=0.28u
X392 XFRONT.XFE_E.XP.t17 E_REGEN_CLK.t24 XFRONT.XFE_E.XN.t17 VDD.t84 pfet_03v3 ad=2.08p pd=8.52u as=2.08p ps=8.52u w=8u l=0.28u
X393 RXP.t2 RXN.t4 VSS.t151 ppolyf_u r_width=4u r_length=1.23u
X394 SAMP_O_N.t0 RX_RESTP.t3 a_10548_44200.t1 VSS.t67 nfet_03v3 ad=2.64p pd=12.88u as=1.56p ps=6.52u w=6u l=0.28u
X395 XFRONT.XFE_O.NREGEN.t12 XFRONT.XFE_O.SB.t14 XFRONT.XFE_O.XP.t5 VSS.t176 nfet_03v3 ad=2.08p pd=8.52u as=3.52p ps=16.88u w=8u l=0.28u
X396 VDD.t565 XFRONT.XFE_E.XP.t47 XFRONT.XFE_E.SXP.t11 VDD.t564 pfet_03v3 ad=2.08p pd=8.52u as=2.08p ps=8.52u w=8u l=0.28u
X397 VSS.t183 FE_O_P.t17 XCAP.ODD_DB_BUF.t8 VSS.t182 nfet_03v3 ad=2.08p pd=8.52u as=3.52p ps=16.88u w=8u l=0.28u
X398 XCAP.O_SET_TAIL.t3 XCAP.ODD_D_BUF.t15 XCAP.O_QBI.t3 VSS.t37 nfet_03v3 ad=2.08p pd=8.52u as=3.52p ps=16.88u w=8u l=0.28u
X399 ODD_Q.t4 XCAP.O_QBBUF.t5 VSS.t178 VSS.t177 nfet_03v3 ad=2.08p pd=8.52u as=2.08p ps=8.52u w=8u l=0.28u
X400 XFRONT.XFE_E.BP.t8 XFRONT.XFE_E.SXP.t20 VDD.t392 VDD.t391 pfet_03v3 ad=3.52p pd=16.88u as=2.08p ps=8.52u w=8u l=0.28u
X401 VSS.t50 FE_E_P.t17 XCAP.EVEN_DB_BUF.t8 VSS.t49 nfet_03v3 ad=2.08p pd=8.52u as=3.52p ps=16.88u w=8u l=0.28u
X402 XFRONT.XFE_E.XN.t11 E_REGEN_CLK.t30 VDD.t228 VDD.t227 pfet_03v3 ad=2.08p pd=8.52u as=2.08p ps=8.52u w=8u l=0.28u
X403 a_n6400_n19852.t1 a_n10800_n19772.t2 a_n7300_n19900.t2 VSS.t322 nfet_03v3 ad=2.6p pd=10.52u as=4.4p ps=20.88u w=10u l=0.28u
X404 XFRONT.XFE_E.NTAIL.t7 E_SENSE_BOOST.t2 VSS.t235 VSS.t234 nfet_03v3 ad=2.08p pd=8.52u as=2.08p ps=8.52u w=8u l=0.28u
X405 XFRONT.XFE_O.NREGEN.t13 XFRONT.XFE_O.XN.t35 XFRONT.XFE_O.XP.t26 VSS.t180 nfet_03v3 ad=3.52p pd=16.88u as=2.08p ps=8.52u w=8u l=0.28u
X406 VDD.t92 XFRONT.XFE_O.XP.t47 XFRONT.XFE_O.SXP.t1 VDD.t91 pfet_03v3 ad=2.08p pd=8.52u as=2.08p ps=8.52u w=8u l=0.28u
X407 VDD.t281 XFRONT.XFE_E.BN.t17 FE_E_P.t9 VDD.t280 pfet_03v3 ad=2.08p pd=8.52u as=2.08p ps=8.52u w=8u l=0.28u
X408 VSS.t291 XFRONT.XFE_O.BP.t13 FE_O_P.t8 VSS.t290 nfet_03v3 ad=2.08p pd=8.52u as=2.08p ps=8.52u w=8u l=0.28u
X409 XCAP.O_PRST_TAIL.t11 O_CAPTURE_CLKB.t8 VDD.t525 VDD.t512 pfet_03v3 ad=3.52p pd=16.88u as=2.08p ps=8.52u w=8u l=0.28u
X410 VSS.t91 O_CAPTURE_CLK.t7 XCAP.O_RST_TAIL.t0 VSS.t90 nfet_03v3 ad=2.08p pd=8.52u as=3.52p ps=16.88u w=8u l=0.28u
X411 VDD.t515 O_CAPTURE_CLKB.t15 XCAP.O_PRST_TAIL.t4 VDD.t514 pfet_03v3 ad=2.08p pd=8.52u as=3.52p ps=16.88u w=8u l=0.28u
X412 VDD.t75 E_REGEN_CLKB.t1 XFRONT.XFE_E.VREGP.t6 VDD.t74 pfet_03v3 ad=2.08p pd=8.52u as=2.08p ps=8.52u w=8u l=0.28u
X413 FE_O_P.t13 XFRONT.XFE_O.BP.t18 VDD.t382 VDD.t381 pfet_03v3 ad=2.08p pd=8.52u as=2.08p ps=8.52u w=8u l=0.28u
X414 XCAP.O_QBI.t11 XCAP.O_QI.t12 VSS.t26 VSS.t1 nfet_03v3 ad=3.52p pd=16.88u as=2.08p ps=8.52u w=8u l=0.28u
X415 XFRONT.XFE_E.SXN.t10 XFRONT.XFE_E.XN.t46 VDD.t543 VDD.t542 pfet_03v3 ad=2.08p pd=8.52u as=2.08p ps=8.52u w=8u l=0.28u
X416 a_n7157_n23500.t2 a_n10800_n23372.t3 a_n6400_n23452.t1 VSS.t318 nfet_03v3 ad=4.4p pd=20.88u as=2.6p ps=10.52u w=10u l=0.28u
X417 a_n10800_n21572.t1 TERM_EN1_N.t2 VSS.t490 VSS.t226 nfet_03v3 ad=0.44p pd=2.88u as=0.44p ps=2.88u w=1u l=0.28u
X418 VSS.t72 RX_BIAS.t5 a_n5052_n1000.t6 VSS.t71 nfet_03v3 ad=4.4p pd=20.88u as=2.6p ps=10.52u w=10u l=0.28u
X419 XCAP.EVEN_D_BUF.t9 FE_E_N.t16 VSS.t313 VSS.t312 nfet_03v3 ad=2.08p pd=8.52u as=2.08p ps=8.52u w=8u l=0.28u
X420 a_n7300_n12700.t1 TERM_EN6_N.t1 a_n6400_n12652.t1 VDD.t218 pfet_03v3 ad=4.4p pd=20.88u as=2.6p ps=10.52u w=10u l=0.28u
X421 XFRONT.XFE_E.XN.t27 XFRONT.XFE_E.XP.t54 XFRONT.XFE_E.VREGN.t11 VDD.t369 pfet_03v3 ad=2.08p pd=8.52u as=2.08p ps=8.52u w=8u l=0.28u
X422 a_n5052_n1000.t8 RXN.t9 a_n3600_5641.t0 VSS.t158 nfet_03v3 ad=2.6p pd=10.52u as=4.4p ps=20.88u w=10u l=0.28u
X423 VDD.t552 a_n1000_22678.t2 VSS.t190 ppolyf_u r_width=2u r_length=4.2u
X424 VSS.t229 E_SENSE_BOOST.t5 XFRONT.XFE_E.NTAIL.t4 VSS.t228 nfet_03v3 ad=2.08p pd=8.52u as=3.52p ps=16.88u w=8u l=0.28u
X425 XFRONT.XFE_O.SXP.t10 XFRONT.XFE_O.XP.t44 VDD.t549 VDD.t548 pfet_03v3 ad=2.08p pd=8.52u as=2.08p ps=8.52u w=8u l=0.28u
X426 VDD.t333 FE_E_N.t21 XCAP.EVEN_D_BUF.t4 VDD.t332 pfet_03v3 ad=2.08p pd=8.52u as=2.08p ps=8.52u w=8u l=0.28u
X427 XCAP.E_QI.t1 XCAP.E_QBI.t12 VSS.t175 VSS.t174 nfet_03v3 ad=3.52p pd=16.88u as=2.08p ps=8.52u w=8u l=0.28u
X428 XFRONT.XFE_O.XP.t21 O_REGEN_CLK.t20 XFRONT.XFE_O.XN.t22 VDD.t191 pfet_03v3 ad=3.52p pd=16.88u as=2.08p ps=8.52u w=8u l=0.28u
X429 FE_O_P.t5 XFRONT.XFE_O.BP.t10 VSS.t199 VSS.t198 nfet_03v3 ad=3.52p pd=16.88u as=2.08p ps=8.52u w=8u l=0.28u
X430 FE_E_N.t8 XFRONT.XFE_E.BP.t20 VDD.t384 VDD.t383 pfet_03v3 ad=2.08p pd=8.52u as=2.08p ps=8.52u w=8u l=0.28u
X431 XCAP.EVEN_DB_BUF.t3 FE_E_P.t22 VDD.t28 VDD.t27 pfet_03v3 ad=2.08p pd=8.52u as=2.08p ps=8.52u w=8u l=0.28u
X432 VSS.t210 XFRONT.XFE_E.BP.t13 FE_E_N.t1 VSS.t209 nfet_03v3 ad=2.08p pd=8.52u as=2.08p ps=8.52u w=8u l=0.28u
X433 XFRONT.XFE_E.VREGP.t3 E_REGEN_CLKB.t4 VDD.t73 VDD.t72 pfet_03v3 ad=2.08p pd=8.52u as=2.08p ps=8.52u w=8u l=0.28u
X434 VSS.t246 E_REGEN_CLK.t3 XFRONT.XFE_E.NREGEN.t19 VSS.t234 nfet_03v3 ad=2.08p pd=8.52u as=2.08p ps=8.52u w=8u l=0.28u
X435 XFRONT.XFE_E.NREGEN.t27 XFRONT.XFE_E.SB.t14 XFRONT.XFE_E.XP.t21 VSS.t474 nfet_03v3 ad=2.08p pd=8.52u as=3.52p ps=16.88u w=8u l=0.28u
X436 ODD_Q.t1 XCAP.O_QBBUF.t7 VDD.t11 VDD.t10 pfet_03v3 ad=3.52p pd=16.88u as=2.08p ps=8.52u w=8u l=0.28u
X437 VDD.t223 E_REGEN_CLK.t11 XFRONT.XFE_E.NREGEN.t11 VDD.t222 pfet_03v3 ad=2.08p pd=8.52u as=3.52p ps=16.88u w=8u l=0.28u
X438 XCAP.O_PSET_TAIL.t1 XCAP.ODD_DB_BUF.t17 XCAP.O_QI.t4 VDD.t2 pfet_03v3 ad=2.08p pd=8.52u as=2.08p ps=8.52u w=8u l=0.28u
X439 XCAP.O_PSET_TAIL.t9 O_CAPTURE_CLKB.t2 VDD.t530 VDD.t510 pfet_03v3 ad=2.08p pd=8.52u as=2.08p ps=8.52u w=8u l=0.28u
X440 VDD.t159 VSS.t510 XFRONT.XFE_O.SA.t0 VDD.t158 pfet_03v3 ad=3.52p pd=16.88u as=3.52p ps=16.88u w=8u l=0.28u
X441 VDD.t55 E_REGEN_CLKB.t13 XFRONT.XFE_E.VREGN.t2 VDD.t54 pfet_03v3 ad=2.08p pd=8.52u as=2.08p ps=8.52u w=8u l=0.28u
X442 XFRONT.XFE_E.VREGP.t8 XFRONT.XFE_E.XN.t57 XFRONT.XFE_E.XP.t26 VDD.t533 pfet_03v3 ad=2.08p pd=8.52u as=3.52p ps=16.88u w=8u l=0.28u
X443 VDD.t139 RX_RESTP.t0 VSS.t190 ppolyf_u r_width=2u r_length=4.2u
X444 XFRONT.XFE_E.SB.t3 E_SENSE_CLK.t5 XFRONT.XFE_E.SA.t3 VDD.t84 pfet_03v3 ad=2.08p pd=8.52u as=3.52p ps=16.88u w=8u l=0.28u
X445 XCAP.E_PSET_TAIL.t8 XCAP.EVEN_DB_BUF.t19 XCAP.E_QI.t3 VDD.t344 pfet_03v3 ad=2.08p pd=8.52u as=3.52p ps=16.88u w=8u l=0.28u
X446 VDD.t471 FE_O_N.t23 XCAP.ODD_D_BUF.t2 VDD.t470 pfet_03v3 ad=2.08p pd=8.52u as=2.08p ps=8.52u w=8u l=0.28u
X447 XFRONT.XFE_O.BP.t7 XFRONT.XFE_O.SXP.t14 VSS.t367 VSS.t366 nfet_03v3 ad=2.08p pd=8.52u as=2.08p ps=8.52u w=8u l=0.28u
X448 XCAP.E_SET_TAIL.t1 XCAP.EVEN_D_BUF.t15 XCAP.E_QBI.t3 VSS.t60 nfet_03v3 ad=2.08p pd=8.52u as=3.52p ps=16.88u w=8u l=0.28u
X449 a_12148_44200.t5 SAMP_CLK_P.t0 a_11748_41600.t1 VSS.t254 nfet_03v3 ad=3.52p pd=16.88u as=2.08p ps=8.52u w=8u l=0.28u
X450 VSS.t333 XFRONT.XFE_E.XP.t41 XFRONT.XFE_E.SXP.t8 VSS.t332 nfet_03v3 ad=2.08p pd=8.52u as=3.52p ps=16.88u w=8u l=0.28u
X451 a_n6400_n14452.t0 RXN.t2 VSS.t147 ppolyf_u r_width=1u r_length=1u
X452 VDD.t450 O_REGEN_CLKB.t5 XFRONT.XFE_O.VREGN.t10 VDD.t449 pfet_03v3 ad=2.08p pd=8.52u as=2.08p ps=8.52u w=8u l=0.28u
X453 XFRONT.XFE_O.VREGP.t12 XFRONT.XFE_O.XN.t53 XFRONT.XFE_O.XP.t29 VDD.t413 pfet_03v3 ad=2.08p pd=8.52u as=2.08p ps=8.52u w=8u l=0.28u
X454 XFRONT.XFE_E.NREGEN.t16 E_REGEN_CLK.t6 VSS.t245 VSS.t228 nfet_03v3 ad=2.08p pd=8.52u as=2.08p ps=8.52u w=8u l=0.28u
X455 VSS.t261 E_CAPTURE_CLK.t7 XCAP.E_RST_TAIL.t0 VSS.t260 nfet_03v3 ad=2.08p pd=8.52u as=3.52p ps=16.88u w=8u l=0.28u
X456 a_n6400_n21652.t2 a_n10800_n21572.t2 a_n7157_n21700.t2 VSS.t416 nfet_03v3 ad=2.6p pd=10.52u as=4.4p ps=20.88u w=10u l=0.28u
X457 VSS.t349 XFRONT.XFE_O.XP.t41 XFRONT.XFE_O.SXP.t9 VSS.t348 nfet_03v3 ad=2.08p pd=8.52u as=3.52p ps=16.88u w=8u l=0.28u
X458 VDD.t244 E_REGEN_CLK.t19 XFRONT.XFE_E.XP.t5 VDD.t243 pfet_03v3 ad=2.08p pd=8.52u as=3.52p ps=16.88u w=8u l=0.28u
X459 VDD.t265 a_n6572_3500.t4 VSS.t285 ppolyf_u r_width=2u r_length=4.57u
X460 VSS.t58 XCAP.E_QBBUF.t4 EVEN_Q.t3 VSS.t57 nfet_03v3 ad=3.52p pd=16.88u as=2.08p ps=8.52u w=8u l=0.28u
X461 XCAP.E_QBI.t9 XCAP.E_QI.t12 VSS.t419 VSS.t277 nfet_03v3 ad=3.52p pd=16.88u as=2.08p ps=8.52u w=8u l=0.28u
X462 XFRONT.XFE_O.XP.t15 O_REGEN_CLK.t26 XFRONT.XFE_O.XN.t24 VDD.t185 pfet_03v3 ad=2.08p pd=8.52u as=2.08p ps=8.52u w=8u l=0.28u
X463 VSS.t453 SAMP_BIAS.t5 a_2148_41600.t6 VSS.t452 nfet_03v3 ad=2.6p pd=10.52u as=2.6p ps=10.52u w=10u l=0.28u
X464 XCAP.E_QI.t10 XCAP.EVEN_DB_BUF.t12 XCAP.E_RST_TAIL.t8 VSS.t267 nfet_03v3 ad=3.52p pd=16.88u as=2.08p ps=8.52u w=8u l=0.28u
X465 XFRONT.XFE_E.SXN.t1 XFRONT.XFE_E.XN.t40 VSS.t478 VSS.t477 nfet_03v3 ad=2.08p pd=8.52u as=2.08p ps=8.52u w=8u l=0.28u
X466 VDD.t147 XFRONT.XFE_O.BP.t21 FE_O_P.t2 VDD.t146 pfet_03v3 ad=2.08p pd=8.52u as=2.08p ps=8.52u w=8u l=0.28u
X467 VDD.t94 a_5300_5958.t0 VSS.t149 ppolyf_u r_width=1u r_length=1.4u
X468 VSS.t431 REST_BIAS.t1 a_n852_19400.t4 VSS.t425 nfet_03v3 ad=3.12p pd=12.52u as=3.12p ps=12.52u w=12u l=0.28u
X469 VDD.t105 SAMP_E_N.t4 VSS.t171 ppolyf_u r_width=2u r_length=5u
X470 XFRONT.XFE_O.XN.t33 XFRONT.XFE_O.XP.t36 XFRONT.XFE_O.NREGEN.t32 VSS.t499 nfet_03v3 ad=2.08p pd=8.52u as=2.08p ps=8.52u w=8u l=0.28u
X471 VDD.t177 O_REGEN_CLK.t31 XFRONT.XFE_O.XP.t10 VDD.t176 pfet_03v3 ad=2.08p pd=8.52u as=2.08p ps=8.52u w=8u l=0.28u
X472 ODD_QB.t6 XCAP.O_QBUF.t9 VDD.t557 VDD.t556 pfet_03v3 ad=2.08p pd=8.52u as=2.08p ps=8.52u w=8u l=0.28u
X473 XFRONT.XFE_O.VREGN.t13 O_REGEN_CLKB.t2 VDD.t456 VDD.t455 pfet_03v3 ad=2.08p pd=8.52u as=2.08p ps=8.52u w=8u l=0.28u
X474 XFRONT.XFE_O.XP.t34 XFRONT.XFE_O.XN.t50 XFRONT.XFE_O.VREGP.t15 VDD.t418 pfet_03v3 ad=3.52p pd=16.88u as=2.08p ps=8.52u w=8u l=0.28u
X475 XFRONT.XFE_E.VREGN.t14 XFRONT.XFE_E.XP.t51 XFRONT.XFE_E.XN.t24 VDD.t559 pfet_03v3 ad=2.08p pd=8.52u as=2.08p ps=8.52u w=8u l=0.28u
X476 a_n852_28800.t2 a_n1000_22678.t4 RX_RESTP.t1 VSS.t133 nfet_03v3 ad=2.6p pd=10.52u as=4.4p ps=20.88u w=10u l=0.28u
X477 XCAP.E_PSET_TAIL.t3 E_CAPTURE_CLKB.t4 VDD.t303 VDD.t302 pfet_03v3 ad=2.08p pd=8.52u as=2.08p ps=8.52u w=8u l=0.28u
X478 a_2548_44200.t4 SAMP_E_N.t6 SAMP_E_P.t4 VSS.t494 nfet_03v3 ad=1.56p pd=6.52u as=2.64p ps=12.88u w=6u l=0.28u
X479 XFRONT.XFE_O.SXP.t6 XFRONT.XFE_O.XP.t38 VSS.t193 VSS.t192 nfet_03v3 ad=3.52p pd=16.88u as=2.08p ps=8.52u w=8u l=0.28u
X480 VDD.t19 XCAP.E_QBUF.t10 EVEN_QB.t1 VDD.t18 pfet_03v3 ad=2.08p pd=8.52u as=3.52p ps=16.88u w=8u l=0.28u
X481 VSS.t187 FE_O_P.t15 XCAP.ODD_DB_BUF.t10 VSS.t186 nfet_03v3 ad=2.08p pd=8.52u as=2.08p ps=8.52u w=8u l=0.28u
X482 XFRONT.XFE_O.XN.t19 O_REGEN_CLK.t23 XFRONT.XFE_O.XP.t18 VDD.t188 pfet_03v3 ad=2.08p pd=8.52u as=2.08p ps=8.52u w=8u l=0.28u
X483 a_n7300_n16300.t3 TERM_EN4_N.t1 a_n6400_n16252.t4 VDD.t463 pfet_03v3 ad=4.4p pd=20.88u as=2.6p ps=10.52u w=10u l=0.28u
X484 XFRONT.XFE_E.BP.t2 XFRONT.XFE_E.SXP.t14 VSS.t339 VSS.t338 nfet_03v3 ad=2.08p pd=8.52u as=2.08p ps=8.52u w=8u l=0.28u
X485 XCAP.O_SET_TAIL.t1 XCAP.ODD_D_BUF.t13 XCAP.O_QBI.t1 VSS.t1 nfet_03v3 ad=2.08p pd=8.52u as=2.08p ps=8.52u w=8u l=0.28u
X486 VSS.t426 REST_BIAS.t5 a_n852_28800.t6 VSS.t425 nfet_03v3 ad=3.12p pd=12.52u as=3.12p ps=12.52u w=12u l=0.28u
X487 FE_O_N.t0 XFRONT.XFE_O.BN.t10 VSS.t335 VSS.t334 nfet_03v3 ad=3.52p pd=16.88u as=2.08p ps=8.52u w=8u l=0.28u
X488 XFRONT.XFE_E.NREGEN.t22 E_REGEN_CLK.t0 VSS.t250 VSS.t249 nfet_03v3 ad=3.52p pd=16.88u as=2.08p ps=8.52u w=8u l=0.28u
X489 a_10548_44200.t2 RX_RESTN.t4 SAMP_O_P.t4 VSS.t137 nfet_03v3 ad=1.56p pd=6.52u as=2.64p ps=12.88u w=6u l=0.28u
X490 XFRONT.XFE_O.XP.t13 O_REGEN_CLK.t28 VDD.t183 VDD.t182 pfet_03v3 ad=3.52p pd=16.88u as=2.08p ps=8.52u w=8u l=0.28u
X491 a_n852_19400.t1 RX_RAWP.t5 a_n1000_22678.t0 VSS.t133 nfet_03v3 ad=2.6p pd=10.52u as=4.4p ps=20.88u w=10u l=0.28u
X492 VSS.t12 O_SENSE_BOOST.t3 XFRONT.XFE_O.NTAIL.t2 VSS.t11 nfet_03v3 ad=2.08p pd=8.52u as=2.08p ps=8.52u w=8u l=0.28u
X493 XFRONT.XFE_E.NREGEN.t26 XFRONT.XFE_E.SA.t10 XFRONT.XFE_E.XN.t33 VSS.t434 nfet_03v3 ad=2.08p pd=8.52u as=2.08p ps=8.52u w=8u l=0.28u
X494 XCAP.ODD_D_BUF.t5 FE_O_N.t20 VDD.t475 VDD.t474 pfet_03v3 ad=2.08p pd=8.52u as=2.08p ps=8.52u w=8u l=0.28u
X495 VDD.t390 XFRONT.XFE_E.BP.t23 FE_E_N.t11 VDD.t389 pfet_03v3 ad=2.08p pd=8.52u as=3.52p ps=16.88u w=8u l=0.28u
X496 VSS.t463 FE_O_N.t15 XCAP.ODD_D_BUF.t10 VSS.t29 nfet_03v3 ad=2.08p pd=8.52u as=2.08p ps=8.52u w=8u l=0.28u
X497 a_948_44200.t5 SAMP_CLK_P.t2 a_2148_41600.t0 VSS.t252 nfet_03v3 ad=3.52p pd=16.88u as=2.08p ps=8.52u w=8u l=0.28u
X498 XCAP.E_PRST_TAIL.t3 E_CAPTURE_CLKB.t14 VDD.t299 VDD.t298 pfet_03v3 ad=2.08p pd=8.52u as=2.08p ps=8.52u w=8u l=0.28u
X499 XFRONT.XFE_E.SXN.t8 XFRONT.XFE_E.XN.t48 VDD.t537 VDD.t536 pfet_03v3 ad=2.08p pd=8.52u as=2.08p ps=8.52u w=8u l=0.28u
X500 VSS.t257 E_CAPTURE_CLK.t11 XCAP.E_SET_TAIL.t6 VSS.t174 nfet_03v3 ad=2.08p pd=8.52u as=2.08p ps=8.52u w=8u l=0.28u
X501 a_n10800_n14372.t0 TERM_EN5_N.t3 VDD.t291 VDD.t290 pfet_03v3 ad=0.88p pd=4.88u as=0.88p ps=4.88u w=2u l=0.28u
X502 XFRONT.XFE_O.NREGEN.t8 XFRONT.XFE_O.SA.t14 XFRONT.XFE_O.XN.t4 VSS.t146 nfet_03v3 ad=2.08p pd=8.52u as=3.52p ps=16.88u w=8u l=0.28u
X503 VSS.t375 XFRONT.XFE_O.SXP.t17 XFRONT.XFE_O.BP.t4 VSS.t374 nfet_03v3 ad=2.08p pd=8.52u as=2.08p ps=8.52u w=8u l=0.28u
X504 XFRONT.XFE_O.XP.t3 XFRONT.XFE_O.SB.t9 XFRONT.XFE_O.NREGEN.t5 VSS.t129 nfet_03v3 ad=2.08p pd=8.52u as=2.08p ps=8.52u w=8u l=0.28u
X505 VSS.t80 RX_BIAS.t7 a_n5052_n1000.t4 VSS.t74 nfet_03v3 ad=2.6p pd=10.52u as=2.6p ps=10.52u w=10u l=0.28u
X506 VSS.t345 XFRONT.XFE_E.SXP.t17 XFRONT.XFE_E.BP.t5 VSS.t344 nfet_03v3 ad=2.08p pd=8.52u as=2.08p ps=8.52u w=8u l=0.28u
X507 XCAP.ODD_DB_BUF.t3 FE_O_P.t22 VDD.t120 VDD.t119 pfet_03v3 ad=2.08p pd=8.52u as=2.08p ps=8.52u w=8u l=0.28u
X508 VDD.t221 E_REGEN_CLK.t35 XFRONT.XFE_E.XN.t6 VDD.t220 pfet_03v3 ad=2.08p pd=8.52u as=3.52p ps=16.88u w=8u l=0.28u
X509 XFRONT.XFE_O.XP.t31 XFRONT.XFE_O.XN.t56 XFRONT.XFE_O.VREGP.t9 VDD.t410 pfet_03v3 ad=2.08p pd=8.52u as=2.08p ps=8.52u w=8u l=0.28u
X510 XCAP.O_QI.t0 XCAP.O_QBI.t16 VDD.t3 VDD.t2 pfet_03v3 ad=3.52p pd=16.88u as=2.08p ps=8.52u w=8u l=0.28u
X511 a_n7300_n19900.t3 TERM_EN2_N.t1 a_n6400_n19852.t3 VDD.t506 pfet_03v3 ad=4.4p pd=20.88u as=2.6p ps=10.52u w=10u l=0.28u
X512 XFRONT.XFE_O.VREGN.t4 XFRONT.XFE_O.XP.t53 XFRONT.XFE_O.XN.t29 VDD.t487 pfet_03v3 ad=2.08p pd=8.52u as=2.08p ps=8.52u w=8u l=0.28u
X513 FE_E_P.t0 XFRONT.XFE_E.BN.t22 VDD.t151 VDD.t150 pfet_03v3 ad=2.08p pd=8.52u as=2.08p ps=8.52u w=8u l=0.28u
X514 a_n6400_n18052.t0 RXN.t0 VSS.t46 ppolyf_u r_width=1u r_length=1u
X515 XFRONT.XFE_O.NTAIL.t5 O_SENSE_BOOST.t0 VSS.t14 VSS.t13 nfet_03v3 ad=3.52p pd=16.88u as=2.08p ps=8.52u w=8u l=0.28u
X516 XFRONT.XFE_E.XN.t3 XFRONT.XFE_E.SA.t13 XFRONT.XFE_E.NREGEN.t6 VSS.t153 nfet_03v3 ad=2.08p pd=8.52u as=2.08p ps=8.52u w=8u l=0.28u
X517 XCAP.O_RST_TAIL.t5 O_CAPTURE_CLK.t2 VSS.t109 VSS.t0 nfet_03v3 ad=2.08p pd=8.52u as=2.08p ps=8.52u w=8u l=0.28u
X518 VSS.t385 XFRONT.XFE_O.SXN.t17 XFRONT.XFE_O.BN.t5 VSS.t384 nfet_03v3 ad=2.08p pd=8.52u as=2.08p ps=8.52u w=8u l=0.28u
X519 ODD_QB.t1 XCAP.O_QBUF.t7 VDD.t9 VDD.t8 pfet_03v3 ad=3.52p pd=16.88u as=2.08p ps=8.52u w=8u l=0.28u
X520 XFRONT.XFE_E.VREGP.t1 E_REGEN_CLKB.t6 VDD.t67 VDD.t66 pfet_03v3 ad=2.08p pd=8.52u as=2.08p ps=8.52u w=8u l=0.28u
X521 XFRONT.XFE_E.XN.t32 XFRONT.XFE_E.XP.t35 XFRONT.XFE_E.NREGEN.t25 VSS.t323 nfet_03v3 ad=3.52p pd=16.88u as=2.08p ps=8.52u w=8u l=0.28u
X522 XCAP.E_SET_TAIL.t3 E_CAPTURE_CLK.t14 VSS.t265 VSS.t264 nfet_03v3 ad=2.08p pd=8.52u as=2.08p ps=8.52u w=8u l=0.28u
X523 XFRONT.XFE_O.SA.t4 O_SENSE_CLK.t6 VDD.t296 VDD.t176 pfet_03v3 ad=3.52p pd=16.88u as=2.08p ps=8.52u w=8u l=0.28u
X524 VDD.t386 XFRONT.XFE_E.BP.t21 FE_E_N.t9 VDD.t385 pfet_03v3 ad=2.08p pd=8.52u as=2.08p ps=8.52u w=8u l=0.28u
X525 XCAP.O_QI.t10 XCAP.ODD_DB_BUF.t14 XCAP.O_RST_TAIL.t10 VSS.t98 nfet_03v3 ad=2.08p pd=8.52u as=2.08p ps=8.52u w=8u l=0.28u
X526 XFRONT.XFE_O.NREGEN.t21 O_REGEN_CLK.t4 VSS.t220 VSS.t11 nfet_03v3 ad=2.08p pd=8.52u as=2.08p ps=8.52u w=8u l=0.28u
X527 VSS.t157 XCAP.O_QBUF.t6 ODD_QB.t3 VSS.t156 nfet_03v3 ad=2.08p pd=8.52u as=3.52p ps=16.88u w=8u l=0.28u
X528 EVEN_QB.t0 XCAP.E_QBUF.t5 VSS.t19 VSS.t18 nfet_03v3 ad=2.08p pd=8.52u as=2.08p ps=8.52u w=8u l=0.28u
X529 XFRONT.XFE_O.XP.t7 O_REGEN_CLK.t34 VDD.t175 VDD.t174 pfet_03v3 ad=2.08p pd=8.52u as=2.08p ps=8.52u w=8u l=0.28u
X530 VDD.t320 E_CAPTURE_CLKB.t1 XCAP.E_PSET_TAIL.t6 VDD.t309 pfet_03v3 ad=2.08p pd=8.52u as=2.08p ps=8.52u w=8u l=0.28u
X531 a_n6400_n14452.t1 TERM_EN5_N.t0 a_n7300_n14500.t1 VDD.t293 pfet_03v3 ad=2.6p pd=10.52u as=4.4p ps=20.88u w=10u l=0.28u
X532 RX_RAWP.t1 a_n6572_3500.t6 a_2148_n500.t6 VSS.t158 nfet_03v3 ad=2.2p pd=10.88u as=1.3p ps=5.52u w=5u l=0.28u
X533 EVEN_QB.t6 XCAP.E_QBUF.t7 VDD.t569 VDD.t568 pfet_03v3 ad=3.52p pd=16.88u as=2.08p ps=8.52u w=8u l=0.28u
X534 XCAP.E_QI.t8 XCAP.EVEN_DB_BUF.t14 XCAP.E_RST_TAIL.t10 VSS.t159 nfet_03v3 ad=2.08p pd=8.52u as=2.08p ps=8.52u w=8u l=0.28u
X535 XFRONT.XFE_E.SXN.t5 XFRONT.XFE_E.XN.t42 VDD.t493 VDD.t492 pfet_03v3 ad=3.52p pd=16.88u as=2.08p ps=8.52u w=8u l=0.28u
X536 XCAP.E_SET_TAIL.t11 XCAP.EVEN_D_BUF.t13 XCAP.E_QBI.t11 VSS.t277 nfet_03v3 ad=2.08p pd=8.52u as=2.08p ps=8.52u w=8u l=0.28u
X537 VDD.t555 a_600_22678.t2 VSS.t132 ppolyf_u r_width=2u r_length=4.2u
X538 VSS.t443 XCAP.E_QBI.t15 XCAP.E_QBUF.t3 VSS.t442 nfet_03v3 ad=1.04p pd=4.52u as=1.76p ps=8.88u w=4u l=0.28u
X539 XFRONT.XFE_E.XN.t18 E_REGEN_CLK.t23 XFRONT.XFE_E.XP.t18 VDD.t85 pfet_03v3 ad=2.08p pd=8.52u as=2.08p ps=8.52u w=8u l=0.28u
X540 XFRONT.XFE_O.XN.t5 XFRONT.XFE_O.XP.t50 XFRONT.XFE_O.VREGN.t7 VDD.t103 pfet_03v3 ad=3.52p pd=16.88u as=2.08p ps=8.52u w=8u l=0.28u
X541 XFRONT.XFE_O.SA.t6 O_SENSE_CLK.t4 XFRONT.XFE_O.SB.t5 VDD.t188 pfet_03v3 ad=3.52p pd=16.88u as=2.08p ps=8.52u w=8u l=0.28u
X542 XFRONT.XFE_O.BN.t9 XFRONT.XFE_O.SXN.t14 VSS.t399 VSS.t398 nfet_03v3 ad=2.08p pd=8.52u as=2.08p ps=8.52u w=8u l=0.28u
X543 a_10548_44200.t0 RX_RESTP.t4 SAMP_O_N.t1 VSS.t66 nfet_03v3 ad=1.56p pd=6.52u as=2.64p ps=12.88u w=6u l=0.28u
X544 RXP.t7 a_n7300_n14500.t4 VSS.t2 ppolyf_u r_width=1u r_length=1u
X545 VSS.t359 XFRONT.XFE_O.BN.t13 FE_O_N.t11 VSS.t358 nfet_03v3 ad=2.08p pd=8.52u as=2.08p ps=8.52u w=8u l=0.28u
X546 VSS.t223 O_REGEN_CLK.t1 XFRONT.XFE_O.NREGEN.t24 VSS.t13 nfet_03v3 ad=2.08p pd=8.52u as=2.08p ps=8.52u w=8u l=0.28u
X547 VDD.t273 XFRONT.XFE_E.XP.t43 XFRONT.XFE_E.SXP.t3 VDD.t272 pfet_03v3 ad=2.08p pd=8.52u as=2.08p ps=8.52u w=8u l=0.28u
X548 XFRONT.XFE_O.XP.t25 XFRONT.XFE_O.XN.t36 XFRONT.XFE_O.NREGEN.t10 VSS.t165 nfet_03v3 ad=2.08p pd=8.52u as=2.08p ps=8.52u w=8u l=0.28u
X549 a_11748_41600.t7 SAMP_BIAS.t0 VSS.t459 VSS.t458 nfet_03v3 ad=4.4p pd=20.88u as=2.6p ps=10.52u w=10u l=0.28u
X550 XFRONT.XFE_E.XN.t1 XFRONT.XFE_E.SA.t7 XFRONT.XFE_E.NREGEN.t4 VSS.t56 nfet_03v3 ad=3.52p pd=16.88u as=2.08p ps=8.52u w=8u l=0.28u
X551 FE_E_P.t8 XFRONT.XFE_E.BN.t16 VDD.t279 VDD.t278 pfet_03v3 ad=3.52p pd=16.88u as=2.08p ps=8.52u w=8u l=0.28u
X552 VDD.t327 FE_E_N.t23 XCAP.EVEN_D_BUF.t2 VDD.t326 pfet_03v3 ad=2.08p pd=8.52u as=2.08p ps=8.52u w=8u l=0.28u
X553 XCAP.EVEN_DB_BUF.t1 FE_E_P.t24 VDD.t30 VDD.t29 pfet_03v3 ad=2.08p pd=8.52u as=2.08p ps=8.52u w=8u l=0.28u
X554 VDD.t497 XCAP.E_QI.t17 XCAP.E_QBI.t6 VDD.t302 pfet_03v3 ad=2.08p pd=8.52u as=3.52p ps=16.88u w=8u l=0.28u
X555 XCAP.ODD_DB_BUF.t5 FE_O_P.t20 VDD.t126 VDD.t125 pfet_03v3 ad=2.08p pd=8.52u as=2.08p ps=8.52u w=8u l=0.28u
X556 XFRONT.XFE_E.VREGP.t7 E_REGEN_CLKB.t0 VDD.t77 VDD.t76 pfet_03v3 ad=3.52p pd=16.88u as=2.08p ps=8.52u w=8u l=0.28u
X557 VDD.t88 RX_RESTN.t1 VSS.t132 ppolyf_u r_width=2u r_length=4.2u
X558 SAMP_E_N.t0 SAMP_E_P.t5 a_2548_44200.t1 VSS.t142 nfet_03v3 ad=2.64p pd=12.88u as=1.56p ps=6.52u w=6u l=0.28u
X559 VDD.t143 XFRONT.XFE_O.BP.t19 FE_O_P.t0 VDD.t142 pfet_03v3 ad=2.08p pd=8.52u as=2.08p ps=8.52u w=8u l=0.28u
X560 VDD.t491 XFRONT.XFE_E.XN.t45 XFRONT.XFE_E.SXN.t4 VDD.t490 pfet_03v3 ad=2.08p pd=8.52u as=2.08p ps=8.52u w=8u l=0.28u
X561 VSS.t28 XCAP.O_QI.t13 XCAP.O_QBI.t10 VSS.t27 nfet_03v3 ad=2.08p pd=8.52u as=3.52p ps=16.88u w=8u l=0.28u
X562 a_n6572_3500.t3 VTHP.t0 a_n5052_2600.t5 VSS.t128 nfet_03v3 ad=0.88p pd=4.88u as=0.52p ps=2.52u w=2u l=0.28u
X563 XFRONT.XFE_E.XP.t15 E_REGEN_CLK.t26 XFRONT.XFE_E.XN.t15 VDD.t238 pfet_03v3 ad=2.08p pd=8.52u as=2.08p ps=8.52u w=8u l=0.28u
X564 VDD.t193 O_REGEN_CLK.t19 XFRONT.XFE_O.XN.t9 VDD.t192 pfet_03v3 ad=2.08p pd=8.52u as=3.52p ps=16.88u w=8u l=0.28u
X565 VSS.t93 O_CAPTURE_CLK.t15 XCAP.O_SET_TAIL.t4 VSS.t92 nfet_03v3 ad=2.08p pd=8.52u as=3.52p ps=16.88u w=8u l=0.28u
X566 a_2148_n500.t1 RX_BIAS.t3 VSS.t81 VSS.t71 nfet_03v3 ad=2.6p pd=10.52u as=2.6p ps=10.52u w=10u l=0.28u
X567 XFRONT.XFE_O.NREGEN.t4 XFRONT.XFE_O.SB.t12 XFRONT.XFE_O.XP.t2 VSS.t127 nfet_03v3 ad=2.08p pd=8.52u as=2.08p ps=8.52u w=8u l=0.28u
X568 VDD.t269 XFRONT.XFE_E.XP.t49 XFRONT.XFE_E.SXP.t1 VDD.t268 pfet_03v3 ad=2.08p pd=8.52u as=3.52p ps=16.88u w=8u l=0.28u
X569 XFRONT.XFE_O.VREGN.t15 O_REGEN_CLKB.t0 VDD.t460 VDD.t459 pfet_03v3 ad=3.52p pd=16.88u as=2.08p ps=8.52u w=8u l=0.28u
X570 XCAP.O_PSET_TAIL.t5 O_CAPTURE_CLKB.t6 VDD.t526 VDD.t517 pfet_03v3 ad=2.08p pd=8.52u as=2.08p ps=8.52u w=8u l=0.28u
X571 VDD.t417 XFRONT.XFE_O.XN.t49 XFRONT.XFE_O.SXN.t2 VDD.t416 pfet_03v3 ad=2.08p pd=8.52u as=3.52p ps=16.88u w=8u l=0.28u
X572 a_n10800_n17972.t0 TERM_EN3_N.t3 VDD.t213 VDD.t212 pfet_03v3 ad=0.88p pd=4.88u as=0.88p ps=4.88u w=2u l=0.28u
X573 SAMP_O_P.t2 SAMP_O_N.t5 a_12148_44200.t3 VSS.t126 nfet_03v3 ad=2.64p pd=12.88u as=1.56p ps=6.52u w=6u l=0.28u
X574 XCAP.E_RST_TAIL.t5 E_CAPTURE_CLK.t2 VSS.t280 VSS.t279 nfet_03v3 ad=2.08p pd=8.52u as=2.08p ps=8.52u w=8u l=0.28u
X575 VDD.t0 a_n1900_5958.t0 VSS.t20 ppolyf_u r_width=1u r_length=1.4u
X576 a_n7157_n21700.t3 TERM_EN1_N.t1 a_n6400_n21652.t4 VDD.t502 pfet_03v3 ad=4.4p pd=20.88u as=2.6p ps=10.52u w=10u l=0.28u
X577 XFRONT.XFE_E.NTAIL.t5 E_SENSE_BOOST.t4 VSS.t231 VSS.t230 nfet_03v3 ad=2.08p pd=8.52u as=2.08p ps=8.52u w=8u l=0.28u
X578 VDD.t551 XFRONT.XFE_O.XP.t45 XFRONT.XFE_O.SXP.t11 VDD.t550 pfet_03v3 ad=2.08p pd=8.52u as=2.08p ps=8.52u w=8u l=0.28u
X579 XFRONT.XFE_O.XN.t21 O_REGEN_CLK.t21 XFRONT.XFE_O.XP.t20 VDD.t190 pfet_03v3 ad=2.08p pd=8.52u as=2.08p ps=8.52u w=8u l=0.28u
X580 XFRONT.XFE_O.XN.t30 XFRONT.XFE_O.XP.t56 XFRONT.XFE_O.VREGN.t1 VDD.t546 pfet_03v3 ad=2.08p pd=8.52u as=2.08p ps=8.52u w=8u l=0.28u
X581 VDD.t402 XFRONT.XFE_E.BN.t19 FE_E_P.t11 VDD.t401 pfet_03v3 ad=2.08p pd=8.52u as=2.08p ps=8.52u w=8u l=0.28u
X582 VSS.t106 O_CAPTURE_CLK.t5 XCAP.O_RST_TAIL.t2 VSS.t37 nfet_03v3 ad=2.08p pd=8.52u as=2.08p ps=8.52u w=8u l=0.28u
X583 XCAP.O_QBUF.t2 XCAP.O_QBI.t14 VSS.t437 VSS.t436 nfet_03v3 ad=1.76p pd=8.88u as=1.04p ps=4.52u w=4u l=0.28u
X584 FE_E_N.t6 XFRONT.XFE_E.BP.t18 VDD.t287 VDD.t286 pfet_03v3 ad=2.08p pd=8.52u as=2.08p ps=8.52u w=8u l=0.28u
X585 VDD.t71 E_REGEN_CLKB.t3 XFRONT.XFE_E.VREGP.t4 VDD.t70 pfet_03v3 ad=2.08p pd=8.52u as=2.08p ps=8.52u w=8u l=0.28u
X586 VDD.t318 E_CAPTURE_CLKB.t5 XCAP.E_PSET_TAIL.t2 VDD.t307 pfet_03v3 ad=2.08p pd=8.52u as=2.08p ps=8.52u w=8u l=0.28u
X587 FE_O_P.t11 XFRONT.XFE_O.BP.t16 VDD.t378 VDD.t377 pfet_03v3 ad=3.52p pd=16.88u as=2.08p ps=8.52u w=8u l=0.28u
X588 XCAP.O_PRST_TAIL.t3 XCAP.ODD_D_BUF.t17 XCAP.O_QBI.t7 VDD.t2 pfet_03v3 ad=2.08p pd=8.52u as=2.08p ps=8.52u w=8u l=0.28u
X589 a_n7300_n12700.t3 a_n10800_n12572.t3 a_n6400_n12652.t3 VSS.t352 nfet_03v3 ad=4.4p pd=20.88u as=2.6p ps=10.52u w=10u l=0.28u
X590 XCAP.O_PRST_TAIL.t9 O_CAPTURE_CLKB.t10 VDD.t511 VDD.t510 pfet_03v3 ad=2.08p pd=8.52u as=2.08p ps=8.52u w=8u l=0.28u
X591 VDD.t360 XFRONT.XFE_O.BN.t23 FE_O_N.t5 VDD.t359 pfet_03v3 ad=2.08p pd=8.52u as=3.52p ps=16.88u w=8u l=0.28u
X592 XFRONT.XFE_E.NREGEN.t12 E_REGEN_CLK.t10 VDD.t257 VDD.t256 pfet_03v3 ad=3.52p pd=16.88u as=2.08p ps=8.52u w=8u l=0.28u
X593 FE_E_P.t2 XFRONT.XFE_E.BN.t10 VSS.t201 VSS.t200 nfet_03v3 ad=3.52p pd=16.88u as=2.08p ps=8.52u w=8u l=0.28u
X594 VDD.t63 E_REGEN_CLKB.t9 XFRONT.XFE_E.VREGN.t6 VDD.t62 pfet_03v3 ad=2.08p pd=8.52u as=2.08p ps=8.52u w=8u l=0.28u
X595 VDD.t432 O_REGEN_CLKB.t15 XFRONT.XFE_O.VREGP.t0 VDD.t431 pfet_03v3 ad=2.08p pd=8.52u as=3.52p ps=16.88u w=8u l=0.28u
X596 XCAP.E_PRST_TAIL.t11 XCAP.EVEN_D_BUF.t19 XCAP.E_QBI.t5 VDD.t344 pfet_03v3 ad=2.08p pd=8.52u as=3.52p ps=16.88u w=8u l=0.28u
X597 EVEN_Q.t4 XCAP.E_QBBUF.t9 VDD.t102 VDD.t101 pfet_03v3 ad=2.08p pd=8.52u as=2.08p ps=8.52u w=8u l=0.28u
X598 XFRONT.XFE_E.XN.t25 XFRONT.XFE_E.XP.t56 XFRONT.XFE_E.VREGN.t9 VDD.t375 pfet_03v3 ad=2.08p pd=8.52u as=2.08p ps=8.52u w=8u l=0.28u
X599 VDD.t93 a_n6716_3500.t0 VSS.t148 ppolyf_u r_width=1u r_length=1.4u
X600 XFRONT.XFE_E.SA.t4 E_SENSE_CLK.t4 XFRONT.XFE_E.SB.t4 VDD.t85 pfet_03v3 ad=3.52p pd=16.88u as=2.08p ps=8.52u w=8u l=0.28u
X601 a_n5052_2600.t4 VTHP.t1 a_n6572_3500.t2 VSS.t128 nfet_03v3 ad=0.52p pd=2.52u as=0.88p ps=4.88u w=2u l=0.28u
X602 XFRONT.XFE_E.BN.t5 XFRONT.XFE_E.SXN.t16 VSS.t405 VSS.t404 nfet_03v3 ad=2.08p pd=8.52u as=2.08p ps=8.52u w=8u l=0.28u
X603 a_n6400_n18052.t1 TERM_EN3_N.t0 a_n7300_n18100.t1 VDD.t215 pfet_03v3 ad=2.6p pd=10.52u as=4.4p ps=20.88u w=10u l=0.28u
X604 a_11748_41600.t0 SAMP_CLK_P.t1 a_12148_44200.t4 VSS.t253 nfet_03v3 ad=2.08p pd=8.52u as=3.52p ps=16.88u w=8u l=0.28u
X605 VSS.t369 XFRONT.XFE_O.SXP.t15 XFRONT.XFE_O.BP.t6 VSS.t368 nfet_03v3 ad=2.08p pd=8.52u as=2.08p ps=8.52u w=8u l=0.28u
X606 XFRONT.XFE_O.SXP.t4 XFRONT.XFE_O.XP.t42 VDD.t136 VDD.t135 pfet_03v3 ad=3.52p pd=16.88u as=2.08p ps=8.52u w=8u l=0.28u
X607 XFRONT.XFE_E.XP.t13 E_REGEN_CLK.t20 XFRONT.XFE_E.XN.t21 VDD.t242 pfet_03v3 ad=3.52p pd=16.88u as=2.08p ps=8.52u w=8u l=0.28u
X608 VSS.t393 XFRONT.XFE_E.SXP.t19 XFRONT.XFE_E.BP.t7 VSS.t392 nfet_03v3 ad=2.08p pd=8.52u as=3.52p ps=16.88u w=8u l=0.28u
X609 a_5300_5958.t1 RX_BW_EN_N.t0 RX_RAWN.t3 VDD.t428 pfet_03v3 ad=2.2p pd=10.88u as=2.2p ps=10.88u w=5u l=0.28u
X610 XFRONT.XFE_O.VREGN.t9 O_REGEN_CLKB.t6 VDD.t438 VDD.t437 pfet_03v3 ad=2.08p pd=8.52u as=2.08p ps=8.52u w=8u l=0.28u
X611 XFRONT.XFE_O.XP.t28 XFRONT.XFE_O.XN.t54 XFRONT.XFE_O.VREGP.t11 VDD.t408 pfet_03v3 ad=2.08p pd=8.52u as=2.08p ps=8.52u w=8u l=0.28u
X612 VSS.t241 E_REGEN_CLK.t5 XFRONT.XFE_E.NREGEN.t17 VSS.t230 nfet_03v3 ad=2.08p pd=8.52u as=2.08p ps=8.52u w=8u l=0.28u
X613 VDD.t331 FE_E_N.t19 XCAP.EVEN_D_BUF.t6 VDD.t330 pfet_03v3 ad=2.08p pd=8.52u as=2.08p ps=8.52u w=8u l=0.28u
X614 VSS.t207 XFRONT.XFE_E.BN.t13 FE_E_P.t5 VSS.t206 nfet_03v3 ad=2.08p pd=8.52u as=2.08p ps=8.52u w=8u l=0.28u
X615 VDD.t264 a_n3600_5641.t4 VSS.t256 ppolyf_u r_width=2u r_length=4.57u
X616 RXP.t6 a_n7300_n18100.t3 VSS.t2 ppolyf_u r_width=1u r_length=1u
X617 VSS.t482 XCAP.E_QI.t13 XCAP.E_QBI.t8 VSS.t59 nfet_03v3 ad=2.08p pd=8.52u as=3.52p ps=16.88u w=8u l=0.28u
X618 VSS.t447 SAMP_BIAS.t3 a_11748_41600.t4 VSS.t446 nfet_03v3 ad=2.6p pd=10.52u as=4.4p ps=20.88u w=10u l=0.28u
X619 a_2148_41600.t5 SAMP_BIAS.t6 VSS.t451 VSS.t450 nfet_03v3 ad=2.6p pd=10.52u as=2.6p ps=10.52u w=10u l=0.28u
X620 XCAP.O_PSET_TAIL.t3 XCAP.ODD_DB_BUF.t19 XCAP.O_QI.t6 VDD.t41 pfet_03v3 ad=2.08p pd=8.52u as=3.52p ps=16.88u w=8u l=0.28u
X621 VDD.t339 XCAP.O_QBBUF.t8 ODD_Q.t5 VDD.t338 pfet_03v3 ad=2.08p pd=8.52u as=2.08p ps=8.52u w=8u l=0.28u
X622 VDD.t53 E_REGEN_CLKB.t15 XFRONT.XFE_E.VREGN.t0 VDD.t52 pfet_03v3 ad=2.08p pd=8.52u as=3.52p ps=16.88u w=8u l=0.28u
X623 VSS.t476 XFRONT.XFE_E.XN.t39 XFRONT.XFE_E.SXN.t0 VSS.t475 nfet_03v3 ad=2.08p pd=8.52u as=2.08p ps=8.52u w=8u l=0.28u
X624 FE_O_P.t3 XFRONT.XFE_O.BP.t22 VDD.t149 VDD.t148 pfet_03v3 ad=2.08p pd=8.52u as=2.08p ps=8.52u w=8u l=0.28u
X625 XFRONT.XFE_O.XN.t1 XFRONT.XFE_O.SA.t9 XFRONT.XFE_O.NREGEN.t2 VSS.t38 nfet_03v3 ad=2.08p pd=8.52u as=2.08p ps=8.52u w=8u l=0.28u
X626 XFRONT.XFE_O.BP.t9 XFRONT.XFE_O.SXP.t12 VSS.t373 VSS.t372 nfet_03v3 ad=3.52p pd=16.88u as=2.08p ps=8.52u w=8u l=0.28u
X627 VSS.t22 XCAP.O_QBUF.t4 ODD_QB.t0 VSS.t21 nfet_03v3 ad=3.52p pd=16.88u as=2.08p ps=8.52u w=8u l=0.28u
X628 XFRONT.XFE_O.XP.t9 O_REGEN_CLK.t32 VDD.t165 VDD.t164 pfet_03v3 ad=2.08p pd=8.52u as=2.08p ps=8.52u w=8u l=0.28u
X629 XCAP.E_PSET_TAIL.t10 XCAP.EVEN_DB_BUF.t17 XCAP.E_QI.t5 VDD.t7 pfet_03v3 ad=2.08p pd=8.52u as=2.08p ps=8.52u w=8u l=0.28u
X630 VDD.t454 O_REGEN_CLKB.t3 XFRONT.XFE_O.VREGN.t12 VDD.t453 pfet_03v3 ad=2.08p pd=8.52u as=2.08p ps=8.52u w=8u l=0.28u
X631 XFRONT.XFE_O.VREGP.t14 XFRONT.XFE_O.XN.t51 XFRONT.XFE_O.XP.t33 VDD.t411 pfet_03v3 ad=2.08p pd=8.52u as=2.08p ps=8.52u w=8u l=0.28u
X632 XCAP.E_PRST_TAIL.t5 E_CAPTURE_CLKB.t12 VDD.t311 VDD.t302 pfet_03v3 ad=2.08p pd=8.52u as=2.08p ps=8.52u w=8u l=0.28u
X633 XCAP.ODD_D_BUF.t1 FE_O_N.t24 VDD.t469 VDD.t468 pfet_03v3 ad=2.08p pd=8.52u as=2.08p ps=8.52u w=8u l=0.28u
X634 VSS.t275 E_CAPTURE_CLK.t5 XCAP.E_RST_TAIL.t2 VSS.t60 nfet_03v3 ad=2.08p pd=8.52u as=2.08p ps=8.52u w=8u l=0.28u
X635 a_n3600_5641.t1 RXN.t8 a_n5052_n1000.t7 VSS.t158 nfet_03v3 ad=4.4p pd=20.88u as=2.6p ps=10.52u w=10u l=0.28u
X636 RX_RESTP.t2 a_n1000_22678.t3 a_n852_28800.t3 VSS.t134 nfet_03v3 ad=4.4p pd=20.88u as=2.6p ps=10.52u w=10u l=0.28u
X637 XFRONT.XFE_E.XN.t29 XFRONT.XFE_E.XP.t50 XFRONT.XFE_E.VREGN.t15 VDD.t558 pfet_03v3 ad=3.52p pd=16.88u as=2.08p ps=8.52u w=8u l=0.28u
X638 VSS.t195 XFRONT.XFE_O.XP.t39 XFRONT.XFE_O.SXP.t7 VSS.t194 nfet_03v3 ad=2.08p pd=8.52u as=2.08p ps=8.52u w=8u l=0.28u
X639 VSS.t237 E_SENSE_BOOST.t1 XFRONT.XFE_E.NTAIL.t8 VSS.t236 nfet_03v3 ad=2.08p pd=8.52u as=2.08p ps=8.52u w=8u l=0.28u
X640 XFRONT.XFE_E.NREGEN.t3 XFRONT.XFE_E.SB.t8 XFRONT.XFE_E.XP.t2 VSS.t55 nfet_03v3 ad=2.08p pd=8.52u as=2.08p ps=8.52u w=8u l=0.28u
X641 XFRONT.XFE_O.SXP.t2 XFRONT.XFE_O.XP.t48 VDD.t109 VDD.t108 pfet_03v3 ad=2.08p pd=8.52u as=2.08p ps=8.52u w=8u l=0.28u
X642 XFRONT.XFE_O.BN.t7 XFRONT.XFE_O.SXN.t12 VSS.t395 VSS.t394 nfet_03v3 ad=3.52p pd=16.88u as=2.08p ps=8.52u w=8u l=0.28u
X643 XFRONT.XFE_O.XP.t17 O_REGEN_CLK.t24 XFRONT.XFE_O.XN.t18 VDD.t187 pfet_03v3 ad=2.08p pd=8.52u as=2.08p ps=8.52u w=8u l=0.28u
X644 VSS.t40 XCAP.E_QBBUF.t6 EVEN_Q.t2 VSS.t39 nfet_03v3 ad=2.08p pd=8.52u as=3.52p ps=16.88u w=8u l=0.28u
X645 XCAP.O_QBI.t2 XCAP.ODD_D_BUF.t14 XCAP.O_SET_TAIL.t2 VSS.t27 nfet_03v3 ad=2.08p pd=8.52u as=2.08p ps=8.52u w=8u l=0.28u
X646 VDD.t181 O_REGEN_CLK.t29 XFRONT.XFE_O.XP.t12 VDD.t180 pfet_03v3 ad=2.08p pd=8.52u as=2.08p ps=8.52u w=8u l=0.28u
X647 a_n1000_22678.t1 RX_RAWP.t4 a_n852_19400.t0 VSS.t134 nfet_03v3 ad=4.4p pd=20.88u as=2.6p ps=10.52u w=10u l=0.28u
X648 XFRONT.XFE_E.XN.t2 XFRONT.XFE_E.SA.t9 XFRONT.XFE_E.NREGEN.t5 VSS.t152 nfet_03v3 ad=2.08p pd=8.52u as=2.08p ps=8.52u w=8u l=0.28u
X649 VSS.t315 FE_E_N.t15 XCAP.EVEN_D_BUF.t10 VSS.t314 nfet_03v3 ad=2.08p pd=8.52u as=2.08p ps=8.52u w=8u l=0.28u
X650 VDD.t112 SAMP_E_P.t2 VSS.t181 ppolyf_u r_width=2u r_length=5u
X651 XCAP.ODD_D_BUF.t9 FE_O_N.t16 VSS.t462 VSS.t41 nfet_03v3 ad=2.08p pd=8.52u as=2.08p ps=8.52u w=8u l=0.28u
X652 VDD.t140 RX_RAWP.t0 VSS.t191 ppolyf_u r_width=2u r_length=3.43u
X653 a_n7300_n16300.t2 a_n10800_n16172.t3 a_n6400_n16252.t2 VSS.t319 nfet_03v3 ad=4.4p pd=20.88u as=2.6p ps=10.52u w=10u l=0.28u
X654 a_n852_19400.t3 REST_BIAS.t2 VSS.t429 VSS.t423 nfet_03v3 ad=3.12p pd=12.52u as=3.12p ps=12.52u w=12u l=0.28u
X655 a_n10800_n14372.t1 TERM_EN5_N.t2 VSS.t303 VSS.t226 nfet_03v3 ad=0.44p pd=2.88u as=0.44p ps=2.88u w=1u l=0.28u
X656 a_2148_41600.t1 SAMP_CLK_P.t3 a_948_44200.t4 VSS.t251 nfet_03v3 ad=2.08p pd=8.52u as=3.52p ps=16.88u w=8u l=0.28u
X657 VDD.t545 XFRONT.XFE_E.XN.t47 XFRONT.XFE_E.SXN.t11 VDD.t544 pfet_03v3 ad=2.08p pd=8.52u as=2.08p ps=8.52u w=8u l=0.28u
X658 XFRONT.XFE_E.VREGN.t12 XFRONT.XFE_E.XP.t53 XFRONT.XFE_E.XN.t22 VDD.t372 pfet_03v3 ad=2.08p pd=8.52u as=2.08p ps=8.52u w=8u l=0.28u
X659 XFRONT.XFE_E.XP.t31 XFRONT.XFE_E.SB.t11 XFRONT.XFE_E.NREGEN.t31 VSS.t497 nfet_03v3 ad=2.08p pd=8.52u as=2.08p ps=8.52u w=8u l=0.28u
X660 VSS.t413 XFRONT.XFE_E.SXN.t13 XFRONT.XFE_E.BN.t8 VSS.t412 nfet_03v3 ad=2.08p pd=8.52u as=2.08p ps=8.52u w=8u l=0.28u
X661 XFRONT.XFE_O.BP.t3 XFRONT.XFE_O.SXP.t18 VSS.t377 VSS.t376 nfet_03v3 ad=2.08p pd=8.52u as=2.08p ps=8.52u w=8u l=0.28u
X662 VDD.t398 XFRONT.XFE_E.SXN.t21 XFRONT.XFE_E.BN.t0 VDD.t397 pfet_03v3 ad=2.08p pd=8.52u as=3.52p ps=16.88u w=8u l=0.28u
X663 a_2148_n500.t3 RX_BIAS.t1 VSS.t84 VSS.t71 nfet_03v3 ad=2.6p pd=10.52u as=2.6p ps=10.52u w=10u l=0.28u
X664 XFRONT.XFE_O.BP.t1 XFRONT.XFE_O.SXP.t20 VDD.t374 VDD.t373 pfet_03v3 ad=3.52p pd=16.88u as=2.08p ps=8.52u w=8u l=0.28u
X665 a_n5052_n1000.t5 RX_BIAS.t6 VSS.t73 VSS.t71 nfet_03v3 ad=2.6p pd=10.52u as=2.6p ps=10.52u w=10u l=0.28u
X666 a_n10800_n23372.t0 TERM_EN0_N.t3 VDD.t346 VDD.t345 pfet_03v3 ad=0.88p pd=4.88u as=0.88p ps=4.88u w=2u l=0.28u
X667 XFRONT.XFE_E.NREGEN.t20 E_REGEN_CLK.t2 VSS.t247 VSS.t236 nfet_03v3 ad=2.08p pd=8.52u as=2.08p ps=8.52u w=8u l=0.28u
X668 XCAP.O_QI.t3 XCAP.ODD_DB_BUF.t16 XCAP.O_PSET_TAIL.t0 VDD.t141 pfet_03v3 ad=3.52p pd=16.88u as=2.08p ps=8.52u w=8u l=0.28u
X669 XFRONT.XFE_O.XN.t7 XFRONT.XFE_O.XP.t54 XFRONT.XFE_O.VREGN.t3 VDD.t133 pfet_03v3 ad=2.08p pd=8.52u as=2.08p ps=8.52u w=8u l=0.28u
X670 VDD.t406 XFRONT.XFE_E.BN.t21 FE_E_P.t13 VDD.t405 pfet_03v3 ad=2.08p pd=8.52u as=2.08p ps=8.52u w=8u l=0.28u
X671 XFRONT.XFE_O.BN.t6 XFRONT.XFE_O.SXN.t18 VSS.t387 VSS.t386 nfet_03v3 ad=2.08p pd=8.52u as=2.08p ps=8.52u w=8u l=0.28u
X672 XFRONT.XFE_E.NREGEN.t32 XFRONT.XFE_E.SA.t12 XFRONT.XFE_E.XN.t34 VSS.t507 nfet_03v3 ad=2.08p pd=8.52u as=2.08p ps=8.52u w=8u l=0.28u
X673 VSS.t108 O_CAPTURE_CLK.t3 XCAP.O_RST_TAIL.t4 VSS.t1 nfet_03v3 ad=2.08p pd=8.52u as=2.08p ps=8.52u w=8u l=0.28u
X674 a_n852_28800.t5 REST_BIAS.t6 VSS.t424 VSS.t423 nfet_03v3 ad=3.12p pd=12.52u as=3.12p ps=12.52u w=12u l=0.28u
X675 VSS.t116 E_SENSE_CLK.t1 XFRONT.XFE_E.NTAIL.t0 VSS.t115 nfet_03v3 ad=2.08p pd=8.52u as=3.52p ps=16.88u w=8u l=0.28u
X676 VSS.t263 E_CAPTURE_CLK.t13 XCAP.E_SET_TAIL.t4 VSS.t262 nfet_03v3 ad=2.08p pd=8.52u as=2.08p ps=8.52u w=8u l=0.28u
X677 XFRONT.XFE_O.XN.t14 O_REGEN_CLK.t14 VDD.t197 VDD.t196 pfet_03v3 ad=2.08p pd=8.52u as=2.08p ps=8.52u w=8u l=0.28u
X678 VDD.t356 XFRONT.XFE_O.BN.t21 FE_O_N.t3 VDD.t355 pfet_03v3 ad=2.08p pd=8.52u as=2.08p ps=8.52u w=8u l=0.28u
X679 VDD.t295 O_SENSE_CLK.t7 XFRONT.XFE_O.SA.t3 VDD.t164 pfet_03v3 ad=2.08p pd=8.52u as=3.52p ps=16.88u w=8u l=0.28u
X680 VDD.t310 E_CAPTURE_CLKB.t9 XCAP.E_PRST_TAIL.t8 VDD.t309 pfet_03v3 ad=2.08p pd=8.52u as=2.08p ps=8.52u w=8u l=0.28u
X681 VDD.t98 XCAP.O_QI.t19 XCAP.O_QBBUF.t0 VDD.t97 pfet_03v3 ad=2.08p pd=8.52u as=3.52p ps=16.88u w=8u l=0.28u
X682 a_n7300_n19900.t1 a_n10800_n19772.t3 a_n6400_n19852.t0 VSS.t63 nfet_03v3 ad=4.4p pd=20.88u as=2.6p ps=10.52u w=10u l=0.28u
X683 XFRONT.XFE_O.NREGEN.t7 XFRONT.XFE_O.SA.t12 XFRONT.XFE_O.XN.t3 VSS.t145 nfet_03v3 ad=2.08p pd=8.52u as=2.08p ps=8.52u w=8u l=0.28u
X684 XFRONT.XFE_O.XP.t23 XFRONT.XFE_O.SB.t7 XFRONT.XFE_O.NREGEN.t30 VSS.t467 nfet_03v3 ad=3.52p pd=16.88u as=2.08p ps=8.52u w=8u l=0.28u
X685 VSS.t75 RX_BIAS.t9 a_n5052_n1000.t2 VSS.t74 nfet_03v3 ad=2.6p pd=10.52u as=4.4p ps=20.88u w=10u l=0.28u
X686 XFRONT.XFE_E.XP.t8 E_REGEN_CLK.t16 VDD.t226 VDD.t86 pfet_03v3 ad=2.08p pd=8.52u as=2.08p ps=8.52u w=8u l=0.28u
X687 a_n6400_n23452.t4 RXN.t7 VSS.t466 ppolyf_u r_width=1u r_length=2.43u
X688 XFRONT.XFE_O.SXN.t5 XFRONT.XFE_O.XN.t44 VDD.t424 VDD.t423 pfet_03v3 ad=2.08p pd=8.52u as=2.08p ps=8.52u w=8u l=0.28u
X689 a_n6400_n23452.t3 TERM_EN0_N.t0 a_n7157_n23500.t4 VDD.t348 pfet_03v3 ad=2.6p pd=10.52u as=4.4p ps=20.88u w=10u l=0.28u
X690 XCAP.EVEN_DB_BUF.t5 FE_E_P.t20 VDD.t36 VDD.t35 pfet_03v3 ad=2.08p pd=8.52u as=2.08p ps=8.52u w=8u l=0.28u
X691 XCAP.E_RST_TAIL.t9 XCAP.EVEN_DB_BUF.t13 XCAP.E_QI.t9 VSS.t174 nfet_03v3 ad=2.08p pd=8.52u as=2.08p ps=8.52u w=8u l=0.28u
X692 XFRONT.XFE_O.NTAIL.t11 O_SENSE_CLK.t0 VSS.t307 VSS.t306 nfet_03v3 ad=3.52p pd=16.88u as=2.08p ps=8.52u w=8u l=0.28u
X693 XCAP.ODD_DB_BUF.t1 FE_O_P.t24 VDD.t118 VDD.t117 pfet_03v3 ad=2.08p pd=8.52u as=2.08p ps=8.52u w=8u l=0.28u
X694 XCAP.E_QBI.t2 XCAP.EVEN_D_BUF.t14 XCAP.E_SET_TAIL.t0 VSS.t59 nfet_03v3 ad=2.08p pd=8.52u as=2.08p ps=8.52u w=8u l=0.28u
X695 XFRONT.XFE_E.XP.t19 E_REGEN_CLK.t22 XFRONT.XFE_E.XN.t19 VDD.t240 pfet_03v3 ad=2.08p pd=8.52u as=2.08p ps=8.52u w=8u l=0.28u
X696 XFRONT.XFE_O.VREGN.t6 XFRONT.XFE_O.XP.t51 XFRONT.XFE_O.XN.t6 VDD.t104 pfet_03v3 ad=2.08p pd=8.52u as=2.08p ps=8.52u w=8u l=0.28u
X697 XFRONT.XFE_O.SA.t2 SAMP_O_P.t7 XFRONT.XFE_O.NTAIL.t6 VSS.t120 nfet_03v3 ad=3.52p pd=16.88u as=2.08p ps=8.52u w=8u l=0.28u
X698 XFRONT.XFE_O.SB.t6 O_SENSE_CLK.t5 XFRONT.XFE_O.SA.t5 VDD.t187 pfet_03v3 ad=2.08p pd=8.52u as=3.52p ps=16.88u w=8u l=0.28u
X699 VSS.t381 XFRONT.XFE_O.SXN.t15 XFRONT.XFE_O.BN.t3 VSS.t380 nfet_03v3 ad=2.08p pd=8.52u as=2.08p ps=8.52u w=8u l=0.28u
X700 XCAP.O_RST_TAIL.t7 O_CAPTURE_CLK.t0 VSS.t113 VSS.t112 nfet_03v3 ad=3.52p pd=16.88u as=2.08p ps=8.52u w=8u l=0.28u
X701 a_n6400_n14452.t3 a_n10800_n14372.t2 a_n7300_n14500.t2 VSS.t320 nfet_03v3 ad=2.6p pd=10.52u as=4.4p ps=20.88u w=10u l=0.28u
X702 XCAP.O_PSET_TAIL.t7 O_CAPTURE_CLKB.t4 VDD.t528 VDD.t16 pfet_03v3 ad=2.08p pd=8.52u as=2.08p ps=8.52u w=8u l=0.28u
X703 XFRONT.XFE_E.XN.t30 XFRONT.XFE_E.XP.t37 XFRONT.XFE_E.NREGEN.t24 VSS.t299 nfet_03v3 ad=2.08p pd=8.52u as=3.52p ps=16.88u w=8u l=0.28u
X704 FE_O_N.t8 XFRONT.XFE_O.BN.t18 VDD.t366 VDD.t365 pfet_03v3 ad=2.08p pd=8.52u as=2.08p ps=8.52u w=8u l=0.28u
X705 XCAP.E_QI.t11 XCAP.E_QBI.t16 VDD.t465 VDD.t7 pfet_03v3 ad=3.52p pd=16.88u as=2.08p ps=8.52u w=8u l=0.28u
X706 XFRONT.XFE_E.SXP.t2 XFRONT.XFE_E.XP.t42 VDD.t271 VDD.t270 pfet_03v3 ad=3.52p pd=16.88u as=2.08p ps=8.52u w=8u l=0.28u
X707 VSS.t297 XFRONT.XFE_E.BN.t15 FE_E_P.t7 VSS.t296 nfet_03v3 ad=2.08p pd=8.52u as=3.52p ps=16.88u w=8u l=0.28u
X708 VSS.t457 SAMP_BIAS.t1 a_11748_41600.t6 VSS.t456 nfet_03v3 ad=2.6p pd=10.52u as=2.6p ps=10.52u w=10u l=0.28u
X709 XFRONT.XFE_O.VREGP.t5 O_REGEN_CLKB.t10 VDD.t442 VDD.t441 pfet_03v3 ad=2.08p pd=8.52u as=2.08p ps=8.52u w=8u l=0.28u
X710 VDD.t1 a_484_3500.t0 VSS.t23 ppolyf_u r_width=1u r_length=1.4u
X711 a_2548_44200.t0 SAMP_E_P.t6 SAMP_E_N.t1 VSS.t141 nfet_03v3 ad=1.56p pd=6.52u as=2.64p ps=12.88u w=6u l=0.28u
X712 VDD.t106 SAMP_O_N.t2 VSS.t172 ppolyf_u r_width=2u r_length=5u
X713 VSS.t506 XFRONT.XFE_E.BP.t11 FE_E_N.t13 VSS.t505 nfet_03v3 ad=2.08p pd=8.52u as=2.08p ps=8.52u w=8u l=0.28u
X714 VSS.t480 XFRONT.XFE_E.XN.t41 XFRONT.XFE_E.SXN.t2 VSS.t479 nfet_03v3 ad=2.08p pd=8.52u as=3.52p ps=16.88u w=8u l=0.28u
X715 FE_O_P.t1 XFRONT.XFE_O.BP.t20 VDD.t145 VDD.t144 pfet_03v3 ad=2.08p pd=8.52u as=2.08p ps=8.52u w=8u l=0.28u
X716 VDD.t301 E_CAPTURE_CLKB.t3 XCAP.E_PSET_TAIL.t4 VDD.t300 pfet_03v3 ad=2.08p pd=8.52u as=2.08p ps=8.52u w=8u l=0.28u
X717 XFRONT.XFE_E.SXN.t3 XFRONT.XFE_E.XN.t44 VDD.t489 VDD.t488 pfet_03v3 ad=2.08p pd=8.52u as=2.08p ps=8.52u w=8u l=0.28u
X718 XFRONT.XFE_E.XN.t16 E_REGEN_CLK.t25 XFRONT.XFE_E.XP.t16 VDD.t239 pfet_03v3 ad=2.08p pd=8.52u as=2.08p ps=8.52u w=8u l=0.28u
R0 TERM_EN0_N.n0 TERM_EN0_N.t1 139.688
R1 TERM_EN0_N.n0 TERM_EN0_N.t0 139.688
R2 TERM_EN0_N.n2 TERM_EN0_N.t3 62.9541
R3 TERM_EN0_N.n1 TERM_EN0_N.t2 49.9184
R4 TERM_EN0_N.n1 TERM_EN0_N.n0 22.445
R5 TERM_EN0_N.n2 TERM_EN0_N.n1 0.8735
R6 TERM_EN0_N TERM_EN0_N.n2 0.539857
R7 TERM_EN1_N.n0 TERM_EN1_N.t1 139.688
R8 TERM_EN1_N.n0 TERM_EN1_N.t0 139.688
R9 TERM_EN1_N.n2 TERM_EN1_N.t3 62.9541
R10 TERM_EN1_N.n1 TERM_EN1_N.t2 49.9184
R11 TERM_EN1_N.n1 TERM_EN1_N.n0 22.445
R12 TERM_EN1_N.n2 TERM_EN1_N.n1 0.8735
R13 TERM_EN1_N TERM_EN1_N.n2 0.539857
R14 TERM_EN2_N.n0 TERM_EN2_N.t1 139.688
R15 TERM_EN2_N.n0 TERM_EN2_N.t0 139.688
R16 TERM_EN2_N.n2 TERM_EN2_N.t3 62.9541
R17 TERM_EN2_N.n1 TERM_EN2_N.t2 49.9184
R18 TERM_EN2_N.n1 TERM_EN2_N.n0 22.445
R19 TERM_EN2_N.n2 TERM_EN2_N.n1 0.8735
R20 TERM_EN2_N TERM_EN2_N.n2 0.539857
R21 TERM_EN3_N.n0 TERM_EN3_N.t1 139.688
R22 TERM_EN3_N.n0 TERM_EN3_N.t0 139.688
R23 TERM_EN3_N.n2 TERM_EN3_N.t3 62.9541
R24 TERM_EN3_N.n1 TERM_EN3_N.t2 49.9184
R25 TERM_EN3_N.n1 TERM_EN3_N.n0 22.445
R26 TERM_EN3_N.n2 TERM_EN3_N.n1 0.8735
R27 TERM_EN3_N TERM_EN3_N.n2 0.539857
R28 TERM_EN4_N.n0 TERM_EN4_N.t1 139.688
R29 TERM_EN4_N.n0 TERM_EN4_N.t0 139.688
R30 TERM_EN4_N.n2 TERM_EN4_N.t3 62.9541
R31 TERM_EN4_N.n1 TERM_EN4_N.t2 49.9184
R32 TERM_EN4_N.n1 TERM_EN4_N.n0 22.445
R33 TERM_EN4_N.n2 TERM_EN4_N.n1 0.8735
R34 TERM_EN4_N TERM_EN4_N.n2 0.539857
R35 TERM_EN5_N.n0 TERM_EN5_N.t1 139.688
R36 TERM_EN5_N.n0 TERM_EN5_N.t0 139.688
R37 TERM_EN5_N.n2 TERM_EN5_N.t3 62.9541
R38 TERM_EN5_N.n1 TERM_EN5_N.t2 49.9184
R39 TERM_EN5_N.n1 TERM_EN5_N.n0 22.445
R40 TERM_EN5_N.n2 TERM_EN5_N.n1 0.8735
R41 TERM_EN5_N TERM_EN5_N.n2 0.539857
R42 TERM_EN6_N.n0 TERM_EN6_N.t1 139.688
R43 TERM_EN6_N.n0 TERM_EN6_N.t0 139.688
R44 TERM_EN6_N.n2 TERM_EN6_N.t3 62.9541
R45 TERM_EN6_N.n1 TERM_EN6_N.t2 49.9184
R46 TERM_EN6_N.n1 TERM_EN6_N.n0 22.445
R47 TERM_EN6_N.n2 TERM_EN6_N.n1 0.8735
R48 TERM_EN6_N TERM_EN6_N.n2 0.539857
R49 RXN.n0 RXN.t8 139.689
R50 RXN.n0 RXN.t9 139.689
R51 RXN.n1 RXN.n0 32.5563
R52 RXN.n2 RXN.t7 16.451
R53 RXN.n7 RXN.t3 15.7257
R54 RXN.n6 RXN.t2 15.7257
R55 RXN.n5 RXN.t1 15.7257
R56 RXN.n4 RXN.t0 15.7257
R57 RXN.n3 RXN.t6 15.7257
R58 RXN.n2 RXN.t5 15.641
R59 RXN.n1 RXN.t4 12.4583
R60 RXN.n3 RXN.n2 0.8105
R61 RXN.n4 RXN.n3 0.8105
R62 RXN.n5 RXN.n4 0.8105
R63 RXN.n6 RXN.n5 0.8105
R64 RXN.n7 RXN.n6 0.8105
R65 RXN RXN.n7 0.6305
R66 RXN RXN.n1 0.1805
R67 RXP.n0 RXP.t8 139.689
R68 RXP.n0 RXP.t9 139.689
R69 RXP.n1 RXP.n0 32.5563
R70 RXP.n2 RXP.t4 16.451
R71 RXP.n3 RXP.t0 15.7257
R72 RXP.n4 RXP.t6 15.7257
R73 RXP.n5 RXP.t1 15.7257
R74 RXP.n6 RXP.t7 15.7257
R75 RXP.n7 RXP.t3 15.7257
R76 RXP.n2 RXP.t5 15.641
R77 RXP.n1 RXP.t2 12.4583
R78 RXP.n3 RXP.n2 0.8105
R79 RXP.n4 RXP.n3 0.8105
R80 RXP.n5 RXP.n4 0.8105
R81 RXP.n6 RXP.n5 0.8105
R82 RXP.n7 RXP.n6 0.8105
R83 RXP RXP.n7 0.6305
R84 RXP RXP.n1 0.1805
R85 RX_BIAS.n4 RX_BIAS.t4 139.702
R86 RX_BIAS.n0 RX_BIAS.t0 139.702
R87 RX_BIAS.n15 RX_BIAS.t9 139.702
R88 RX_BIAS.n11 RX_BIAS.t5 139.702
R89 RX_BIAS.n1 RX_BIAS.t1 135.246
R90 RX_BIAS.n2 RX_BIAS.t2 135.246
R91 RX_BIAS.n3 RX_BIAS.t3 135.246
R92 RX_BIAS.n12 RX_BIAS.t6 135.246
R93 RX_BIAS.n13 RX_BIAS.t7 135.246
R94 RX_BIAS.n14 RX_BIAS.t8 135.246
R95 RX_BIAS.n6 RX_BIAS.t10 35.4171
R96 RX_BIAS.n9 RX_BIAS.t13 35.4171
R97 RX_BIAS.n7 RX_BIAS.t11 30.9603
R98 RX_BIAS.n8 RX_BIAS.t12 30.9603
R99 RX_BIAS.n17 RX_BIAS.n10 21.4384
R100 RX_BIAS.n18 RX_BIAS.n5 18.9479
R101 RX_BIAS.n5 RX_BIAS.n2 18.4942
R102 RX_BIAS.n16 RX_BIAS.n13 18.4942
R103 RX_BIAS.n17 RX_BIAS.n16 18.0005
R104 RX_BIAS.n8 RX_BIAS.n7 11.6805
R105 RX_BIAS.n2 RX_BIAS.n1 11.6805
R106 RX_BIAS.n3 RX_BIAS.n2 11.6805
R107 RX_BIAS.n13 RX_BIAS.n12 11.6805
R108 RX_BIAS.n14 RX_BIAS.n13 11.6805
R109 RX_BIAS RX_BIAS.n18 7.56892
R110 RX_BIAS.n5 RX_BIAS.n0 7.16487
R111 RX_BIAS.n5 RX_BIAS.n4 7.16487
R112 RX_BIAS.n16 RX_BIAS.n11 7.16487
R113 RX_BIAS.n16 RX_BIAS.n15 7.16487
R114 RX_BIAS.n10 RX_BIAS.n6 7.09873
R115 RX_BIAS.n10 RX_BIAS.n9 7.09873
R116 RX_BIAS.n7 RX_BIAS.n6 4.42851
R117 RX_BIAS.n9 RX_BIAS.n8 4.42851
R118 RX_BIAS.n1 RX_BIAS.n0 4.42851
R119 RX_BIAS.n4 RX_BIAS.n3 4.42851
R120 RX_BIAS.n12 RX_BIAS.n11 4.42851
R121 RX_BIAS.n15 RX_BIAS.n14 4.42851
R122 RX_BIAS.n18 RX_BIAS.n17 0.947868
R123 VTHN.n0 VTHN.t0 35.4171
R124 VTHN.n0 VTHN.t1 35.3883
R125 VTHN VTHN.n0 35.0111
R126 VTHP.n0 VTHP.t1 35.4171
R127 VTHP.n0 VTHP.t0 35.3883
R128 VTHP VTHP.n0 34.2271
R129 RX_BW_EN_N.n0 RX_BW_EN_N.t0 104.718
R130 RX_BW_EN_N.n2 RX_BW_EN_N.t3 102.35
R131 RX_BW_EN_N.n1 RX_BW_EN_N.t2 102.35
R132 RX_BW_EN_N.n0 RX_BW_EN_N.t1 102.35
R133 RX_BW_EN_N RX_BW_EN_N.n2 2.55971
R134 RX_BW_EN_N.n2 RX_BW_EN_N.n1 2.36892
R135 RX_BW_EN_N.n1 RX_BW_EN_N.n0 1.89524
R136 RX_RAWN.n0 RX_RAWN.t4 139.689
R137 RX_RAWN.n0 RX_RAWN.t5 139.689
R138 RX_RAWN RX_RAWN.n0 36.4661
R139 RX_RAWN.n3 RX_RAWN.t0 12.5711
R140 RX_RAWN.n2 RX_RAWN.t3 10.6142
R141 RX_RAWN RX_RAWN.n3 6.39524
R142 RX_RAWN.n1 RX_RAWN.t2 6.0676
R143 RX_RAWN.n1 RX_RAWN.t1 6.06436
R144 RX_RAWN.n2 RX_RAWN.n1 3.78254
R145 RX_RAWN.n3 RX_RAWN.n2 0.491409
R146 RX_RAWP.n0 RX_RAWP.t4 139.689
R147 RX_RAWP.n0 RX_RAWP.t5 139.689
R148 RX_RAWP RX_RAWP.n0 36.3761
R149 RX_RAWP.n3 RX_RAWP.t0 12.5711
R150 RX_RAWP.n2 RX_RAWP.t2 10.6142
R151 RX_RAWP RX_RAWP.n3 6.39524
R152 RX_RAWP.n1 RX_RAWP.t1 6.0676
R153 RX_RAWP.n1 RX_RAWP.t3 6.06436
R154 RX_RAWP.n2 RX_RAWP.n1 3.78254
R155 RX_RAWP.n3 RX_RAWP.n2 0.491409
R156 REST_BIAS.n8 REST_BIAS.t3 165.774
R157 REST_BIAS.n5 REST_BIAS.t0 165.774
R158 REST_BIAS.n0 REST_BIAS.t4 165.774
R159 REST_BIAS.n3 REST_BIAS.t7 165.774
R160 REST_BIAS.n6 REST_BIAS.t1 161.317
R161 REST_BIAS.n7 REST_BIAS.t2 161.317
R162 REST_BIAS.n1 REST_BIAS.t5 161.317
R163 REST_BIAS.n2 REST_BIAS.t6 161.317
R164 REST_BIAS.n10 REST_BIAS.n4 19.0663
R165 REST_BIAS.n10 REST_BIAS.n9 13.5005
R166 REST_BIAS.n7 REST_BIAS.n6 11.6805
R167 REST_BIAS.n2 REST_BIAS.n1 11.6805
R168 REST_BIAS.n9 REST_BIAS.n5 7.10487
R169 REST_BIAS.n9 REST_BIAS.n8 7.10487
R170 REST_BIAS.n4 REST_BIAS.n0 7.10487
R171 REST_BIAS.n4 REST_BIAS.n3 7.10487
R172 REST_BIAS REST_BIAS.n10 6.38708
R173 REST_BIAS.n6 REST_BIAS.n5 4.42851
R174 REST_BIAS.n8 REST_BIAS.n7 4.42851
R175 REST_BIAS.n1 REST_BIAS.n0 4.42851
R176 REST_BIAS.n3 REST_BIAS.n2 4.42851
R177 SAMP_BIAS.n3 SAMP_BIAS.t3 139.702
R178 SAMP_BIAS.n0 SAMP_BIAS.t0 139.702
R179 SAMP_BIAS.n5 SAMP_BIAS.t4 139.702
R180 SAMP_BIAS.n8 SAMP_BIAS.t7 139.702
R181 SAMP_BIAS.n1 SAMP_BIAS.t1 135.246
R182 SAMP_BIAS.n2 SAMP_BIAS.t2 135.246
R183 SAMP_BIAS.n6 SAMP_BIAS.t5 135.246
R184 SAMP_BIAS.n7 SAMP_BIAS.t6 135.246
R185 SAMP_BIAS.n10 SAMP_BIAS.n4 19.1847
R186 SAMP_BIAS.n10 SAMP_BIAS.n9 13.5005
R187 SAMP_BIAS SAMP_BIAS.n10 12.8674
R188 SAMP_BIAS.n2 SAMP_BIAS.n1 11.6805
R189 SAMP_BIAS.n7 SAMP_BIAS.n6 11.6805
R190 SAMP_BIAS.n4 SAMP_BIAS.n0 7.10487
R191 SAMP_BIAS.n4 SAMP_BIAS.n3 7.10487
R192 SAMP_BIAS.n9 SAMP_BIAS.n5 7.10487
R193 SAMP_BIAS.n9 SAMP_BIAS.n8 7.10487
R194 SAMP_BIAS.n1 SAMP_BIAS.n0 4.42851
R195 SAMP_BIAS.n3 SAMP_BIAS.n2 4.42851
R196 SAMP_BIAS.n6 SAMP_BIAS.n5 4.42851
R197 SAMP_BIAS.n8 SAMP_BIAS.n7 4.42851
R198 SAMP_CLK_N.n1 SAMP_CLK_N.t1 113.618
R199 SAMP_CLK_N.n1 SAMP_CLK_N.t0 113.618
R200 SAMP_CLK_N.n0 SAMP_CLK_N.t3 113.618
R201 SAMP_CLK_N.n0 SAMP_CLK_N.t2 113.618
R202 SAMP_CLK_N.n2 SAMP_CLK_N.n1 25.1703
R203 SAMP_CLK_N.n2 SAMP_CLK_N.n0 20.9071
R204 SAMP_CLK_N SAMP_CLK_N.n2 13.1872
R205 SAMP_CLK_P.n1 SAMP_CLK_P.t1 113.618
R206 SAMP_CLK_P.n1 SAMP_CLK_P.t0 113.618
R207 SAMP_CLK_P.n0 SAMP_CLK_P.t3 113.618
R208 SAMP_CLK_P.n0 SAMP_CLK_P.t2 113.618
R209 SAMP_CLK_P.n2 SAMP_CLK_P.n1 28.3203
R210 SAMP_CLK_P.n2 SAMP_CLK_P.n0 25.1624
R211 SAMP_CLK_P SAMP_CLK_P.n2 5.7165
R212 RX_RESTP.n1 RX_RESTP.t5 87.5461
R213 RX_RESTP.n1 RX_RESTP.t6 87.5461
R214 RX_RESTP.n0 RX_RESTP.t3 87.5461
R215 RX_RESTP.n0 RX_RESTP.t4 87.5461
R216 RX_RESTP.n2 RX_RESTP.n0 31.2488
R217 RX_RESTP.n2 RX_RESTP.n1 25.5646
R218 RX_RESTP RX_RESTP.n2 14.1979
R219 RX_RESTP.n4 RX_RESTP.t0 12.57
R220 RX_RESTP RX_RESTP.n4 11.8991
R221 RX_RESTP.n3 RX_RESTP.t1 6.0613
R222 RX_RESTP.n3 RX_RESTP.t2 6.0613
R223 RX_RESTP.n4 RX_RESTP.n3 2.77532
R224 RX_RESTN.n0 RX_RESTN.t5 87.5461
R225 RX_RESTN.n0 RX_RESTN.t6 87.5461
R226 RX_RESTN.n1 RX_RESTN.t3 87.5461
R227 RX_RESTN.n1 RX_RESTN.t4 87.5461
R228 RX_RESTN.n2 RX_RESTN.n1 22.0262
R229 RX_RESTN.n2 RX_RESTN.n0 16.342
R230 RX_RESTN.n4 RX_RESTN.t1 12.57
R231 RX_RESTN RX_RESTN.n4 9.30958
R232 RX_RESTN RX_RESTN.n2 9.17813
R233 RX_RESTN.n3 RX_RESTN.t2 6.0613
R234 RX_RESTN.n3 RX_RESTN.t0 6.0613
R235 RX_RESTN.n4 RX_RESTN.n3 2.77532
R236 O_SENSE_BOOST.n3 O_SENSE_BOOST.t5 113.632
R237 O_SENSE_BOOST.n0 O_SENSE_BOOST.t0 109.174
R238 O_SENSE_BOOST.n7 O_SENSE_BOOST.t1 109.174
R239 O_SENSE_BOOST.n6 O_SENSE_BOOST.t2 109.174
R240 O_SENSE_BOOST.n5 O_SENSE_BOOST.t3 109.174
R241 O_SENSE_BOOST.n2 O_SENSE_BOOST.t4 109.174
R242 O_SENSE_BOOST O_SENSE_BOOST.n9 34.2009
R243 O_SENSE_BOOST.n9 O_SENSE_BOOST.n0 18.5636
R244 O_SENSE_BOOST.n8 O_SENSE_BOOST.n7 18.4942
R245 O_SENSE_BOOST.n6 O_SENSE_BOOST.n1 18.4942
R246 O_SENSE_BOOST.n5 O_SENSE_BOOST.n4 18.4942
R247 O_SENSE_BOOST.n7 O_SENSE_BOOST.n0 11.6805
R248 O_SENSE_BOOST.n7 O_SENSE_BOOST.n6 11.6805
R249 O_SENSE_BOOST.n6 O_SENSE_BOOST.n5 11.6805
R250 O_SENSE_BOOST.n5 O_SENSE_BOOST.n2 11.6805
R251 O_SENSE_BOOST.n4 O_SENSE_BOOST.n3 7.17687
R252 O_SENSE_BOOST.n3 O_SENSE_BOOST.n2 4.42851
R253 O_SENSE_BOOST.n4 O_SENSE_BOOST.n1 0.1205
R254 O_SENSE_BOOST.n8 O_SENSE_BOOST.n1 0.1205
R255 O_SENSE_BOOST.n9 O_SENSE_BOOST.n8 0.0485
R256 SAMP_O_N.n10 SAMP_O_N.t7 113.618
R257 SAMP_O_N.n10 SAMP_O_N.t8 113.618
R258 SAMP_O_N.n1 SAMP_O_N.t5 87.5461
R259 SAMP_O_N.n1 SAMP_O_N.t6 87.5461
R260 SAMP_O_N SAMP_O_N.n10 54.516
R261 SAMP_O_N.n2 SAMP_O_N.n1 26.3217
R262 SAMP_O_N SAMP_O_N.n9 14.2502
R263 SAMP_O_N.n9 SAMP_O_N.t2 12.4596
R264 SAMP_O_N.n0 SAMP_O_N.t0 5.96544
R265 SAMP_O_N.n0 SAMP_O_N.t1 5.9622
R266 SAMP_O_N.n5 SAMP_O_N.t4 5.87051
R267 SAMP_O_N.n4 SAMP_O_N.t3 5.87051
R268 SAMP_O_N.n4 SAMP_O_N.n3 4.5005
R269 SAMP_O_N.n6 SAMP_O_N.n5 4.5005
R270 SAMP_O_N.n8 SAMP_O_N.n0 2.56391
R271 SAMP_O_N.n9 SAMP_O_N.n8 0.8805
R272 SAMP_O_N.n7 SAMP_O_N.n2 0.419
R273 SAMP_O_N.n8 SAMP_O_N.n7 0.2415
R274 SAMP_O_N.n5 SAMP_O_N.n4 0.189974
R275 SAMP_O_N.n6 SAMP_O_N.n3 0.1605
R276 SAMP_O_N.n7 SAMP_O_N.n6 0.0795
R277 SAMP_O_N.n3 SAMP_O_N.n2 0.0740593
R278 SAMP_O_P.n10 SAMP_O_P.t7 113.618
R279 SAMP_O_P.n10 SAMP_O_P.t8 113.618
R280 SAMP_O_P.n0 SAMP_O_P.t5 87.5461
R281 SAMP_O_P.n0 SAMP_O_P.t6 87.5461
R282 SAMP_O_P SAMP_O_P.n10 49.414
R283 SAMP_O_P.n1 SAMP_O_P.n0 35.3132
R284 SAMP_O_P SAMP_O_P.n9 14.2502
R285 SAMP_O_P.n9 SAMP_O_P.t0 12.4596
R286 SAMP_O_P.n7 SAMP_O_P.t4 5.96544
R287 SAMP_O_P.n7 SAMP_O_P.t3 5.9622
R288 SAMP_O_P.n3 SAMP_O_P.t2 5.87051
R289 SAMP_O_P.n4 SAMP_O_P.t1 5.87051
R290 SAMP_O_P.n5 SAMP_O_P.n4 4.5005
R291 SAMP_O_P.n3 SAMP_O_P.n2 4.5005
R292 SAMP_O_P.n8 SAMP_O_P.n7 2.56391
R293 SAMP_O_P.n9 SAMP_O_P.n8 0.8805
R294 SAMP_O_P.n6 SAMP_O_P.n1 0.419
R295 SAMP_O_P.n8 SAMP_O_P.n6 0.2415
R296 SAMP_O_P.n4 SAMP_O_P.n3 0.189974
R297 SAMP_O_P.n5 SAMP_O_P.n2 0.1605
R298 SAMP_O_P.n6 SAMP_O_P.n5 0.0795
R299 SAMP_O_P.n2 SAMP_O_P.n1 0.0405
R300 E_SENSE_BOOST.n3 E_SENSE_BOOST.t0 113.632
R301 E_SENSE_BOOST.n4 E_SENSE_BOOST.t1 109.174
R302 E_SENSE_BOOST.n5 E_SENSE_BOOST.t2 109.174
R303 E_SENSE_BOOST.n6 E_SENSE_BOOST.t3 109.174
R304 E_SENSE_BOOST.n7 E_SENSE_BOOST.t4 109.174
R305 E_SENSE_BOOST.n8 E_SENSE_BOOST.t5 109.174
R306 E_SENSE_BOOST E_SENSE_BOOST.n9 34.2009
R307 E_SENSE_BOOST.n9 E_SENSE_BOOST.n8 18.5636
R308 E_SENSE_BOOST.n5 E_SENSE_BOOST.n2 18.4942
R309 E_SENSE_BOOST.n6 E_SENSE_BOOST.n1 18.4942
R310 E_SENSE_BOOST.n7 E_SENSE_BOOST.n0 18.4942
R311 E_SENSE_BOOST.n5 E_SENSE_BOOST.n4 11.6805
R312 E_SENSE_BOOST.n6 E_SENSE_BOOST.n5 11.6805
R313 E_SENSE_BOOST.n7 E_SENSE_BOOST.n6 11.6805
R314 E_SENSE_BOOST.n8 E_SENSE_BOOST.n7 11.6805
R315 E_SENSE_BOOST.n3 E_SENSE_BOOST.n2 7.17687
R316 E_SENSE_BOOST.n4 E_SENSE_BOOST.n3 4.42851
R317 E_SENSE_BOOST.n1 E_SENSE_BOOST.n0 0.1205
R318 E_SENSE_BOOST.n2 E_SENSE_BOOST.n1 0.1205
R319 E_SENSE_BOOST.n9 E_SENSE_BOOST.n0 0.0485
R320 SAMP_E_N.n10 SAMP_E_N.t7 113.618
R321 SAMP_E_N.n10 SAMP_E_N.t8 113.618
R322 SAMP_E_N.n1 SAMP_E_N.t5 87.5461
R323 SAMP_E_N.n1 SAMP_E_N.t6 87.5461
R324 SAMP_E_N SAMP_E_N.n10 49.414
R325 SAMP_E_N.n2 SAMP_E_N.n1 26.3484
R326 SAMP_E_N SAMP_E_N.n9 14.2502
R327 SAMP_E_N.n9 SAMP_E_N.t4 12.4596
R328 SAMP_E_N.n0 SAMP_E_N.t2 5.96544
R329 SAMP_E_N.n0 SAMP_E_N.t3 5.9622
R330 SAMP_E_N.n5 SAMP_E_N.t0 5.87051
R331 SAMP_E_N.n4 SAMP_E_N.t1 5.87051
R332 SAMP_E_N.n4 SAMP_E_N.n3 4.5005
R333 SAMP_E_N.n6 SAMP_E_N.n5 4.5005
R334 SAMP_E_N.n8 SAMP_E_N.n0 2.56391
R335 SAMP_E_N.n9 SAMP_E_N.n8 0.8805
R336 SAMP_E_N.n7 SAMP_E_N.n2 0.419
R337 SAMP_E_N.n8 SAMP_E_N.n7 0.2415
R338 SAMP_E_N.n5 SAMP_E_N.n4 0.189974
R339 SAMP_E_N.n6 SAMP_E_N.n3 0.1605
R340 SAMP_E_N.n7 SAMP_E_N.n6 0.0795
R341 SAMP_E_N.n3 SAMP_E_N.n2 0.0405
R342 SAMP_E_P.n10 SAMP_E_P.t7 113.618
R343 SAMP_E_P.n10 SAMP_E_P.t8 113.618
R344 SAMP_E_P.n0 SAMP_E_P.t5 87.5461
R345 SAMP_E_P.n0 SAMP_E_P.t6 87.5461
R346 SAMP_E_P SAMP_E_P.n10 54.516
R347 SAMP_E_P.n1 SAMP_E_P.n0 35.155
R348 SAMP_E_P SAMP_E_P.n9 14.2502
R349 SAMP_E_P.n9 SAMP_E_P.t2 12.4596
R350 SAMP_E_P.n7 SAMP_E_P.t0 5.96544
R351 SAMP_E_P.n7 SAMP_E_P.t1 5.9622
R352 SAMP_E_P.n3 SAMP_E_P.t3 5.87051
R353 SAMP_E_P.n4 SAMP_E_P.t4 5.87051
R354 SAMP_E_P.n5 SAMP_E_P.n4 4.5005
R355 SAMP_E_P.n3 SAMP_E_P.n2 4.5005
R356 SAMP_E_P.n8 SAMP_E_P.n7 2.56391
R357 SAMP_E_P.n9 SAMP_E_P.n8 0.8805
R358 SAMP_E_P.n6 SAMP_E_P.n1 0.419
R359 SAMP_E_P.n8 SAMP_E_P.n6 0.2415
R360 SAMP_E_P.n4 SAMP_E_P.n3 0.189974
R361 SAMP_E_P.n5 SAMP_E_P.n2 0.1605
R362 SAMP_E_P.n6 SAMP_E_P.n5 0.0795
R363 SAMP_E_P.n2 SAMP_E_P.n1 0.0740593
R364 O_SENSE_CLK.n0 O_SENSE_CLK.t2 113.632
R365 O_SENSE_CLK.n1 O_SENSE_CLK.t5 113.632
R366 O_SENSE_CLK.n5 O_SENSE_CLK.t6 113.632
R367 O_SENSE_CLK.n3 O_SENSE_CLK.t0 113.618
R368 O_SENSE_CLK.n3 O_SENSE_CLK.t1 113.618
R369 O_SENSE_CLK.n0 O_SENSE_CLK.t3 113.603
R370 O_SENSE_CLK.n1 O_SENSE_CLK.t4 113.603
R371 O_SENSE_CLK.n5 O_SENSE_CLK.t7 113.603
R372 O_SENSE_CLK.n6 O_SENSE_CLK.n5 35.4506
R373 O_SENSE_CLK.n4 O_SENSE_CLK.n2 22.7641
R374 O_SENSE_CLK O_SENSE_CLK.n6 18.6466
R375 O_SENSE_CLK.n4 O_SENSE_CLK.n3 16.0613
R376 O_SENSE_CLK.n6 O_SENSE_CLK.n4 9.38566
R377 O_SENSE_CLK.n2 O_SENSE_CLK.n0 7.88487
R378 O_SENSE_CLK.n2 O_SENSE_CLK.n1 7.88487
R379 E_SENSE_CLK.n5 E_SENSE_CLK.t3 113.632
R380 E_SENSE_CLK.n0 E_SENSE_CLK.t4 113.632
R381 E_SENSE_CLK.n1 E_SENSE_CLK.t7 113.632
R382 E_SENSE_CLK.n3 E_SENSE_CLK.t0 113.618
R383 E_SENSE_CLK.n3 E_SENSE_CLK.t1 113.618
R384 E_SENSE_CLK.n5 E_SENSE_CLK.t2 113.603
R385 E_SENSE_CLK.n0 E_SENSE_CLK.t5 113.603
R386 E_SENSE_CLK.n1 E_SENSE_CLK.t6 113.603
R387 E_SENSE_CLK.n6 E_SENSE_CLK.n5 35.4506
R388 E_SENSE_CLK.n4 E_SENSE_CLK.n2 22.7641
R389 E_SENSE_CLK E_SENSE_CLK.n6 18.6466
R390 E_SENSE_CLK.n4 E_SENSE_CLK.n3 16.0613
R391 E_SENSE_CLK.n6 E_SENSE_CLK.n4 9.38566
R392 E_SENSE_CLK.n2 E_SENSE_CLK.n0 7.88487
R393 E_SENSE_CLK.n2 E_SENSE_CLK.n1 7.88487
R394 O_REGEN_CLK.t12 O_REGEN_CLK.n72 127.788
R395 O_REGEN_CLK.t35 O_REGEN_CLK.n32 127.788
R396 O_REGEN_CLK.t20 O_REGEN_CLK.n11 127.788
R397 O_REGEN_CLK.t19 O_REGEN_CLK.n61 127.668
R398 O_REGEN_CLK.n72 O_REGEN_CLK.t13 127.668
R399 O_REGEN_CLK.n71 O_REGEN_CLK.t14 127.668
R400 O_REGEN_CLK.n70 O_REGEN_CLK.t15 127.668
R401 O_REGEN_CLK.n69 O_REGEN_CLK.t16 127.668
R402 O_REGEN_CLK.n68 O_REGEN_CLK.t17 127.668
R403 O_REGEN_CLK.n67 O_REGEN_CLK.t18 127.668
R404 O_REGEN_CLK.t27 O_REGEN_CLK.n20 127.668
R405 O_REGEN_CLK.t28 O_REGEN_CLK.n41 127.668
R406 O_REGEN_CLK.n40 O_REGEN_CLK.t29 127.668
R407 O_REGEN_CLK.n32 O_REGEN_CLK.t34 127.668
R408 O_REGEN_CLK.n31 O_REGEN_CLK.t33 127.668
R409 O_REGEN_CLK.n30 O_REGEN_CLK.t32 127.668
R410 O_REGEN_CLK.t31 O_REGEN_CLK.n25 127.668
R411 O_REGEN_CLK.n39 O_REGEN_CLK.t30 127.668
R412 O_REGEN_CLK.n11 O_REGEN_CLK.t21 127.668
R413 O_REGEN_CLK.n10 O_REGEN_CLK.t22 127.668
R414 O_REGEN_CLK.n9 O_REGEN_CLK.t23 127.668
R415 O_REGEN_CLK.t24 O_REGEN_CLK.n4 127.668
R416 O_REGEN_CLK.n18 O_REGEN_CLK.t25 127.668
R417 O_REGEN_CLK.n19 O_REGEN_CLK.t26 127.668
R418 O_REGEN_CLK.n84 O_REGEN_CLK.t8 113.632
R419 O_REGEN_CLK.n0 O_REGEN_CLK.t10 113.632
R420 O_REGEN_CLK.n73 O_REGEN_CLK.t12 113.632
R421 O_REGEN_CLK.n48 O_REGEN_CLK.t7 113.632
R422 O_REGEN_CLK.n52 O_REGEN_CLK.t0 113.632
R423 O_REGEN_CLK.n33 O_REGEN_CLK.t35 113.632
R424 O_REGEN_CLK.n12 O_REGEN_CLK.t20 113.632
R425 O_REGEN_CLK.n84 O_REGEN_CLK.t9 113.603
R426 O_REGEN_CLK.n0 O_REGEN_CLK.t11 113.603
R427 O_REGEN_CLK.n80 O_REGEN_CLK.t19 109.174
R428 O_REGEN_CLK.n74 O_REGEN_CLK.t13 109.174
R429 O_REGEN_CLK.n75 O_REGEN_CLK.t14 109.174
R430 O_REGEN_CLK.n76 O_REGEN_CLK.t15 109.174
R431 O_REGEN_CLK.n77 O_REGEN_CLK.t16 109.174
R432 O_REGEN_CLK.n78 O_REGEN_CLK.t17 109.174
R433 O_REGEN_CLK.n79 O_REGEN_CLK.t18 109.174
R434 O_REGEN_CLK.n55 O_REGEN_CLK.t3 109.174
R435 O_REGEN_CLK.n56 O_REGEN_CLK.t4 109.174
R436 O_REGEN_CLK.n49 O_REGEN_CLK.t6 109.174
R437 O_REGEN_CLK.n50 O_REGEN_CLK.t5 109.174
R438 O_REGEN_CLK.n54 O_REGEN_CLK.t2 109.174
R439 O_REGEN_CLK.n51 O_REGEN_CLK.t1 109.174
R440 O_REGEN_CLK.n21 O_REGEN_CLK.t27 109.174
R441 O_REGEN_CLK.n42 O_REGEN_CLK.t28 109.174
R442 O_REGEN_CLK.t29 O_REGEN_CLK.n24 109.174
R443 O_REGEN_CLK.n34 O_REGEN_CLK.t34 109.174
R444 O_REGEN_CLK.n35 O_REGEN_CLK.t33 109.174
R445 O_REGEN_CLK.n36 O_REGEN_CLK.t32 109.174
R446 O_REGEN_CLK.n37 O_REGEN_CLK.t31 109.174
R447 O_REGEN_CLK.t30 O_REGEN_CLK.n38 109.174
R448 O_REGEN_CLK.n13 O_REGEN_CLK.t21 109.174
R449 O_REGEN_CLK.n14 O_REGEN_CLK.t22 109.174
R450 O_REGEN_CLK.n15 O_REGEN_CLK.t23 109.174
R451 O_REGEN_CLK.n16 O_REGEN_CLK.t24 109.174
R452 O_REGEN_CLK.t25 O_REGEN_CLK.n17 109.174
R453 O_REGEN_CLK.t26 O_REGEN_CLK.n3 109.174
R454 O_REGEN_CLK.n60 O_REGEN_CLK.n0 27.7007
R455 O_REGEN_CLK.n85 O_REGEN_CLK.n84 22.692
R456 O_REGEN_CLK.n59 O_REGEN_CLK.n58 20.0962
R457 O_REGEN_CLK.n81 O_REGEN_CLK.n80 18.4942
R458 O_REGEN_CLK.n75 O_REGEN_CLK.n66 18.4942
R459 O_REGEN_CLK.n76 O_REGEN_CLK.n65 18.4942
R460 O_REGEN_CLK.n77 O_REGEN_CLK.n64 18.4942
R461 O_REGEN_CLK.n78 O_REGEN_CLK.n63 18.4942
R462 O_REGEN_CLK.n79 O_REGEN_CLK.n62 18.4942
R463 O_REGEN_CLK.n55 O_REGEN_CLK.n46 18.4942
R464 O_REGEN_CLK.n57 O_REGEN_CLK.n56 18.4942
R465 O_REGEN_CLK.n50 O_REGEN_CLK.n47 18.4942
R466 O_REGEN_CLK.n54 O_REGEN_CLK.n53 18.4942
R467 O_REGEN_CLK.n22 O_REGEN_CLK.n21 18.4942
R468 O_REGEN_CLK.n43 O_REGEN_CLK.n42 18.4942
R469 O_REGEN_CLK.n24 O_REGEN_CLK.n23 18.4942
R470 O_REGEN_CLK.n35 O_REGEN_CLK.n29 18.4942
R471 O_REGEN_CLK.n36 O_REGEN_CLK.n28 18.4942
R472 O_REGEN_CLK.n37 O_REGEN_CLK.n27 18.4942
R473 O_REGEN_CLK.n38 O_REGEN_CLK.n26 18.4942
R474 O_REGEN_CLK.n14 O_REGEN_CLK.n8 18.4942
R475 O_REGEN_CLK.n15 O_REGEN_CLK.n7 18.4942
R476 O_REGEN_CLK.n16 O_REGEN_CLK.n6 18.4942
R477 O_REGEN_CLK.n17 O_REGEN_CLK.n5 18.4942
R478 O_REGEN_CLK.n3 O_REGEN_CLK.n2 18.4942
R479 O_REGEN_CLK O_REGEN_CLK.n85 15.9857
R480 O_REGEN_CLK.n75 O_REGEN_CLK.n74 11.6805
R481 O_REGEN_CLK.n76 O_REGEN_CLK.n75 11.6805
R482 O_REGEN_CLK.n77 O_REGEN_CLK.n76 11.6805
R483 O_REGEN_CLK.n78 O_REGEN_CLK.n77 11.6805
R484 O_REGEN_CLK.n79 O_REGEN_CLK.n78 11.6805
R485 O_REGEN_CLK.n80 O_REGEN_CLK.n79 11.6805
R486 O_REGEN_CLK.n55 O_REGEN_CLK.n54 11.6805
R487 O_REGEN_CLK.n56 O_REGEN_CLK.n55 11.6805
R488 O_REGEN_CLK.n50 O_REGEN_CLK.n49 11.6805
R489 O_REGEN_CLK.n56 O_REGEN_CLK.n50 11.6805
R490 O_REGEN_CLK.n54 O_REGEN_CLK.n51 11.6805
R491 O_REGEN_CLK.n42 O_REGEN_CLK.n24 11.6805
R492 O_REGEN_CLK.n35 O_REGEN_CLK.n34 11.6805
R493 O_REGEN_CLK.n36 O_REGEN_CLK.n35 11.6805
R494 O_REGEN_CLK.n37 O_REGEN_CLK.n36 11.6805
R495 O_REGEN_CLK.n38 O_REGEN_CLK.n37 11.6805
R496 O_REGEN_CLK.n38 O_REGEN_CLK.n24 11.6805
R497 O_REGEN_CLK.n14 O_REGEN_CLK.n13 11.6805
R498 O_REGEN_CLK.n15 O_REGEN_CLK.n14 11.6805
R499 O_REGEN_CLK.n16 O_REGEN_CLK.n15 11.6805
R500 O_REGEN_CLK.n17 O_REGEN_CLK.n16 11.6805
R501 O_REGEN_CLK.n17 O_REGEN_CLK.n3 11.6805
R502 O_REGEN_CLK.n21 O_REGEN_CLK.n3 11.6805
R503 O_REGEN_CLK.n82 O_REGEN_CLK.n61 10.8876
R504 O_REGEN_CLK.n45 O_REGEN_CLK.n1 10.8396
R505 O_REGEN_CLK.n83 O_REGEN_CLK.n82 10.3248
R506 O_REGEN_CLK.n82 O_REGEN_CLK.n81 9.0485
R507 O_REGEN_CLK.n45 O_REGEN_CLK.n44 9.0005
R508 O_REGEN_CLK.n73 O_REGEN_CLK.n66 7.17687
R509 O_REGEN_CLK.n53 O_REGEN_CLK.n52 7.17687
R510 O_REGEN_CLK.n48 O_REGEN_CLK.n47 7.17687
R511 O_REGEN_CLK.n33 O_REGEN_CLK.n29 7.17687
R512 O_REGEN_CLK.n12 O_REGEN_CLK.n8 7.17687
R513 O_REGEN_CLK.n59 O_REGEN_CLK.n45 5.82479
R514 O_REGEN_CLK.n60 O_REGEN_CLK.n59 4.5005
R515 O_REGEN_CLK.n74 O_REGEN_CLK.n73 4.42851
R516 O_REGEN_CLK.n49 O_REGEN_CLK.n48 4.42851
R517 O_REGEN_CLK.n52 O_REGEN_CLK.n51 4.42851
R518 O_REGEN_CLK.n34 O_REGEN_CLK.n33 4.42851
R519 O_REGEN_CLK.n13 O_REGEN_CLK.n12 4.42851
R520 O_REGEN_CLK.n85 O_REGEN_CLK.n83 3.83528
R521 O_REGEN_CLK.n83 O_REGEN_CLK.n60 2.89615
R522 O_REGEN_CLK.n44 O_REGEN_CLK.n22 0.4685
R523 O_REGEN_CLK.n20 O_REGEN_CLK.n1 0.4685
R524 O_REGEN_CLK.n41 O_REGEN_CLK.n1 0.4685
R525 O_REGEN_CLK.n44 O_REGEN_CLK.n43 0.4685
R526 O_REGEN_CLK.n81 O_REGEN_CLK.n62 0.1205
R527 O_REGEN_CLK.n63 O_REGEN_CLK.n62 0.1205
R528 O_REGEN_CLK.n64 O_REGEN_CLK.n63 0.1205
R529 O_REGEN_CLK.n65 O_REGEN_CLK.n64 0.1205
R530 O_REGEN_CLK.n66 O_REGEN_CLK.n65 0.1205
R531 O_REGEN_CLK.n67 O_REGEN_CLK.n61 0.1205
R532 O_REGEN_CLK.n68 O_REGEN_CLK.n67 0.1205
R533 O_REGEN_CLK.n69 O_REGEN_CLK.n68 0.1205
R534 O_REGEN_CLK.n70 O_REGEN_CLK.n69 0.1205
R535 O_REGEN_CLK.n71 O_REGEN_CLK.n70 0.1205
R536 O_REGEN_CLK.n72 O_REGEN_CLK.n71 0.1205
R537 O_REGEN_CLK.n53 O_REGEN_CLK.n46 0.1205
R538 O_REGEN_CLK.n57 O_REGEN_CLK.n47 0.1205
R539 O_REGEN_CLK.n22 O_REGEN_CLK.n2 0.1205
R540 O_REGEN_CLK.n5 O_REGEN_CLK.n2 0.1205
R541 O_REGEN_CLK.n6 O_REGEN_CLK.n5 0.1205
R542 O_REGEN_CLK.n7 O_REGEN_CLK.n6 0.1205
R543 O_REGEN_CLK.n8 O_REGEN_CLK.n7 0.1205
R544 O_REGEN_CLK.n20 O_REGEN_CLK.n19 0.1205
R545 O_REGEN_CLK.n19 O_REGEN_CLK.n18 0.1205
R546 O_REGEN_CLK.n18 O_REGEN_CLK.n4 0.1205
R547 O_REGEN_CLK.n9 O_REGEN_CLK.n4 0.1205
R548 O_REGEN_CLK.n10 O_REGEN_CLK.n9 0.1205
R549 O_REGEN_CLK.n11 O_REGEN_CLK.n10 0.1205
R550 O_REGEN_CLK.n32 O_REGEN_CLK.n31 0.1205
R551 O_REGEN_CLK.n31 O_REGEN_CLK.n30 0.1205
R552 O_REGEN_CLK.n30 O_REGEN_CLK.n25 0.1205
R553 O_REGEN_CLK.n39 O_REGEN_CLK.n25 0.1205
R554 O_REGEN_CLK.n40 O_REGEN_CLK.n39 0.1205
R555 O_REGEN_CLK.n41 O_REGEN_CLK.n40 0.1205
R556 O_REGEN_CLK.n29 O_REGEN_CLK.n28 0.1205
R557 O_REGEN_CLK.n28 O_REGEN_CLK.n27 0.1205
R558 O_REGEN_CLK.n27 O_REGEN_CLK.n26 0.1205
R559 O_REGEN_CLK.n26 O_REGEN_CLK.n23 0.1205
R560 O_REGEN_CLK.n43 O_REGEN_CLK.n23 0.1205
R561 O_REGEN_CLK.n58 O_REGEN_CLK.n46 0.0485
R562 O_REGEN_CLK.n58 O_REGEN_CLK.n57 0.0485
R563 E_REGEN_CLK.t27 E_REGEN_CLK.n34 127.788
R564 E_REGEN_CLK.t12 E_REGEN_CLK.n11 127.788
R565 E_REGEN_CLK.n69 E_REGEN_CLK.t35 127.788
R566 E_REGEN_CLK.t19 E_REGEN_CLK.n20 127.668
R567 E_REGEN_CLK.n34 E_REGEN_CLK.t26 127.668
R568 E_REGEN_CLK.n33 E_REGEN_CLK.t25 127.668
R569 E_REGEN_CLK.n32 E_REGEN_CLK.t24 127.668
R570 E_REGEN_CLK.n31 E_REGEN_CLK.t23 127.668
R571 E_REGEN_CLK.n30 E_REGEN_CLK.t22 127.668
R572 E_REGEN_CLK.n29 E_REGEN_CLK.t21 127.668
R573 E_REGEN_CLK.n28 E_REGEN_CLK.t20 127.668
R574 E_REGEN_CLK.n11 E_REGEN_CLK.t13 127.668
R575 E_REGEN_CLK.n10 E_REGEN_CLK.t14 127.668
R576 E_REGEN_CLK.n9 E_REGEN_CLK.t15 127.668
R577 E_REGEN_CLK.t16 E_REGEN_CLK.n4 127.668
R578 E_REGEN_CLK.n18 E_REGEN_CLK.t17 127.668
R579 E_REGEN_CLK.n19 E_REGEN_CLK.t18 127.668
R580 E_REGEN_CLK.t28 E_REGEN_CLK.n61 127.668
R581 E_REGEN_CLK.t29 E_REGEN_CLK.n78 127.668
R582 E_REGEN_CLK.n77 E_REGEN_CLK.t30 127.668
R583 E_REGEN_CLK.n76 E_REGEN_CLK.t31 127.668
R584 E_REGEN_CLK.t32 E_REGEN_CLK.n64 127.668
R585 E_REGEN_CLK.t33 E_REGEN_CLK.n70 127.668
R586 E_REGEN_CLK.n69 E_REGEN_CLK.t34 127.668
R587 E_REGEN_CLK.n0 E_REGEN_CLK.t9 113.632
R588 E_REGEN_CLK.n84 E_REGEN_CLK.t11 113.632
R589 E_REGEN_CLK.n48 E_REGEN_CLK.t7 113.632
R590 E_REGEN_CLK.n52 E_REGEN_CLK.t0 113.632
R591 E_REGEN_CLK.n35 E_REGEN_CLK.t27 113.632
R592 E_REGEN_CLK.n12 E_REGEN_CLK.t12 113.632
R593 E_REGEN_CLK.t35 E_REGEN_CLK.n67 113.632
R594 E_REGEN_CLK.n0 E_REGEN_CLK.t8 113.603
R595 E_REGEN_CLK.n84 E_REGEN_CLK.t10 113.603
R596 E_REGEN_CLK.n55 E_REGEN_CLK.t3 109.174
R597 E_REGEN_CLK.n56 E_REGEN_CLK.t4 109.174
R598 E_REGEN_CLK.n49 E_REGEN_CLK.t6 109.174
R599 E_REGEN_CLK.n50 E_REGEN_CLK.t5 109.174
R600 E_REGEN_CLK.n54 E_REGEN_CLK.t2 109.174
R601 E_REGEN_CLK.n51 E_REGEN_CLK.t1 109.174
R602 E_REGEN_CLK.n21 E_REGEN_CLK.t19 109.174
R603 E_REGEN_CLK.t26 E_REGEN_CLK.n27 109.174
R604 E_REGEN_CLK.n37 E_REGEN_CLK.t25 109.174
R605 E_REGEN_CLK.n38 E_REGEN_CLK.t24 109.174
R606 E_REGEN_CLK.n39 E_REGEN_CLK.t23 109.174
R607 E_REGEN_CLK.n40 E_REGEN_CLK.t22 109.174
R608 E_REGEN_CLK.n41 E_REGEN_CLK.t21 109.174
R609 E_REGEN_CLK.n42 E_REGEN_CLK.t20 109.174
R610 E_REGEN_CLK.n13 E_REGEN_CLK.t13 109.174
R611 E_REGEN_CLK.n14 E_REGEN_CLK.t14 109.174
R612 E_REGEN_CLK.n15 E_REGEN_CLK.t15 109.174
R613 E_REGEN_CLK.n16 E_REGEN_CLK.t16 109.174
R614 E_REGEN_CLK.t17 E_REGEN_CLK.n17 109.174
R615 E_REGEN_CLK.t18 E_REGEN_CLK.n3 109.174
R616 E_REGEN_CLK.n80 E_REGEN_CLK.t28 109.174
R617 E_REGEN_CLK.n79 E_REGEN_CLK.t29 109.174
R618 E_REGEN_CLK.t30 E_REGEN_CLK.n63 109.174
R619 E_REGEN_CLK.t31 E_REGEN_CLK.n75 109.174
R620 E_REGEN_CLK.n65 E_REGEN_CLK.t32 109.174
R621 E_REGEN_CLK.n71 E_REGEN_CLK.t33 109.174
R622 E_REGEN_CLK.t34 E_REGEN_CLK.n68 109.174
R623 E_REGEN_CLK.n60 E_REGEN_CLK.n0 27.7007
R624 E_REGEN_CLK.n85 E_REGEN_CLK.n84 22.692
R625 E_REGEN_CLK.n59 E_REGEN_CLK.n58 20.0962
R626 E_REGEN_CLK.n55 E_REGEN_CLK.n46 18.4942
R627 E_REGEN_CLK.n57 E_REGEN_CLK.n56 18.4942
R628 E_REGEN_CLK.n50 E_REGEN_CLK.n47 18.4942
R629 E_REGEN_CLK.n54 E_REGEN_CLK.n53 18.4942
R630 E_REGEN_CLK.n22 E_REGEN_CLK.n21 18.4942
R631 E_REGEN_CLK.n37 E_REGEN_CLK.n36 18.4942
R632 E_REGEN_CLK.n38 E_REGEN_CLK.n26 18.4942
R633 E_REGEN_CLK.n39 E_REGEN_CLK.n25 18.4942
R634 E_REGEN_CLK.n40 E_REGEN_CLK.n24 18.4942
R635 E_REGEN_CLK.n41 E_REGEN_CLK.n23 18.4942
R636 E_REGEN_CLK.n43 E_REGEN_CLK.n42 18.4942
R637 E_REGEN_CLK.n14 E_REGEN_CLK.n8 18.4942
R638 E_REGEN_CLK.n15 E_REGEN_CLK.n7 18.4942
R639 E_REGEN_CLK.n16 E_REGEN_CLK.n6 18.4942
R640 E_REGEN_CLK.n17 E_REGEN_CLK.n5 18.4942
R641 E_REGEN_CLK.n3 E_REGEN_CLK.n2 18.4942
R642 E_REGEN_CLK.n81 E_REGEN_CLK.n80 18.4942
R643 E_REGEN_CLK.n79 E_REGEN_CLK.n62 18.4942
R644 E_REGEN_CLK.n66 E_REGEN_CLK.n63 18.4942
R645 E_REGEN_CLK.n75 E_REGEN_CLK.n74 18.4942
R646 E_REGEN_CLK.n73 E_REGEN_CLK.n65 18.4942
R647 E_REGEN_CLK.n72 E_REGEN_CLK.n71 18.4942
R648 E_REGEN_CLK E_REGEN_CLK.n85 15.9857
R649 E_REGEN_CLK.n55 E_REGEN_CLK.n54 11.6805
R650 E_REGEN_CLK.n56 E_REGEN_CLK.n55 11.6805
R651 E_REGEN_CLK.n50 E_REGEN_CLK.n49 11.6805
R652 E_REGEN_CLK.n56 E_REGEN_CLK.n50 11.6805
R653 E_REGEN_CLK.n54 E_REGEN_CLK.n51 11.6805
R654 E_REGEN_CLK.n38 E_REGEN_CLK.n37 11.6805
R655 E_REGEN_CLK.n37 E_REGEN_CLK.n27 11.6805
R656 E_REGEN_CLK.n39 E_REGEN_CLK.n38 11.6805
R657 E_REGEN_CLK.n40 E_REGEN_CLK.n39 11.6805
R658 E_REGEN_CLK.n41 E_REGEN_CLK.n40 11.6805
R659 E_REGEN_CLK.n42 E_REGEN_CLK.n41 11.6805
R660 E_REGEN_CLK.n14 E_REGEN_CLK.n13 11.6805
R661 E_REGEN_CLK.n15 E_REGEN_CLK.n14 11.6805
R662 E_REGEN_CLK.n16 E_REGEN_CLK.n15 11.6805
R663 E_REGEN_CLK.n17 E_REGEN_CLK.n16 11.6805
R664 E_REGEN_CLK.n17 E_REGEN_CLK.n3 11.6805
R665 E_REGEN_CLK.n21 E_REGEN_CLK.n3 11.6805
R666 E_REGEN_CLK.n80 E_REGEN_CLK.n79 11.6805
R667 E_REGEN_CLK.n79 E_REGEN_CLK.n63 11.6805
R668 E_REGEN_CLK.n75 E_REGEN_CLK.n63 11.6805
R669 E_REGEN_CLK.n75 E_REGEN_CLK.n65 11.6805
R670 E_REGEN_CLK.n71 E_REGEN_CLK.n65 11.6805
R671 E_REGEN_CLK.n71 E_REGEN_CLK.n68 11.6805
R672 E_REGEN_CLK.n82 E_REGEN_CLK.n61 10.8876
R673 E_REGEN_CLK.n45 E_REGEN_CLK.n1 10.8396
R674 E_REGEN_CLK.n83 E_REGEN_CLK.n82 10.3248
R675 E_REGEN_CLK.n82 E_REGEN_CLK.n81 9.0485
R676 E_REGEN_CLK.n45 E_REGEN_CLK.n44 9.0005
R677 E_REGEN_CLK.n53 E_REGEN_CLK.n52 7.17687
R678 E_REGEN_CLK.n48 E_REGEN_CLK.n47 7.17687
R679 E_REGEN_CLK.n36 E_REGEN_CLK.n35 7.17687
R680 E_REGEN_CLK.n12 E_REGEN_CLK.n8 7.17687
R681 E_REGEN_CLK.n72 E_REGEN_CLK.n67 7.17687
R682 E_REGEN_CLK.n59 E_REGEN_CLK.n45 5.82479
R683 E_REGEN_CLK.n60 E_REGEN_CLK.n59 4.5005
R684 E_REGEN_CLK.n49 E_REGEN_CLK.n48 4.42851
R685 E_REGEN_CLK.n52 E_REGEN_CLK.n51 4.42851
R686 E_REGEN_CLK.n35 E_REGEN_CLK.n27 4.42851
R687 E_REGEN_CLK.n13 E_REGEN_CLK.n12 4.42851
R688 E_REGEN_CLK.n68 E_REGEN_CLK.n67 4.42851
R689 E_REGEN_CLK.n85 E_REGEN_CLK.n83 3.83528
R690 E_REGEN_CLK.n83 E_REGEN_CLK.n60 2.89615
R691 E_REGEN_CLK.n44 E_REGEN_CLK.n22 0.4685
R692 E_REGEN_CLK.n20 E_REGEN_CLK.n1 0.4685
R693 E_REGEN_CLK.n28 E_REGEN_CLK.n1 0.4685
R694 E_REGEN_CLK.n44 E_REGEN_CLK.n43 0.4685
R695 E_REGEN_CLK.n53 E_REGEN_CLK.n46 0.1205
R696 E_REGEN_CLK.n57 E_REGEN_CLK.n47 0.1205
R697 E_REGEN_CLK.n22 E_REGEN_CLK.n2 0.1205
R698 E_REGEN_CLK.n5 E_REGEN_CLK.n2 0.1205
R699 E_REGEN_CLK.n6 E_REGEN_CLK.n5 0.1205
R700 E_REGEN_CLK.n7 E_REGEN_CLK.n6 0.1205
R701 E_REGEN_CLK.n8 E_REGEN_CLK.n7 0.1205
R702 E_REGEN_CLK.n20 E_REGEN_CLK.n19 0.1205
R703 E_REGEN_CLK.n19 E_REGEN_CLK.n18 0.1205
R704 E_REGEN_CLK.n18 E_REGEN_CLK.n4 0.1205
R705 E_REGEN_CLK.n9 E_REGEN_CLK.n4 0.1205
R706 E_REGEN_CLK.n10 E_REGEN_CLK.n9 0.1205
R707 E_REGEN_CLK.n11 E_REGEN_CLK.n10 0.1205
R708 E_REGEN_CLK.n34 E_REGEN_CLK.n33 0.1205
R709 E_REGEN_CLK.n33 E_REGEN_CLK.n32 0.1205
R710 E_REGEN_CLK.n32 E_REGEN_CLK.n31 0.1205
R711 E_REGEN_CLK.n31 E_REGEN_CLK.n30 0.1205
R712 E_REGEN_CLK.n30 E_REGEN_CLK.n29 0.1205
R713 E_REGEN_CLK.n29 E_REGEN_CLK.n28 0.1205
R714 E_REGEN_CLK.n36 E_REGEN_CLK.n26 0.1205
R715 E_REGEN_CLK.n26 E_REGEN_CLK.n25 0.1205
R716 E_REGEN_CLK.n25 E_REGEN_CLK.n24 0.1205
R717 E_REGEN_CLK.n24 E_REGEN_CLK.n23 0.1205
R718 E_REGEN_CLK.n43 E_REGEN_CLK.n23 0.1205
R719 E_REGEN_CLK.n73 E_REGEN_CLK.n72 0.1205
R720 E_REGEN_CLK.n74 E_REGEN_CLK.n73 0.1205
R721 E_REGEN_CLK.n74 E_REGEN_CLK.n66 0.1205
R722 E_REGEN_CLK.n66 E_REGEN_CLK.n62 0.1205
R723 E_REGEN_CLK.n81 E_REGEN_CLK.n62 0.1205
R724 E_REGEN_CLK.n70 E_REGEN_CLK.n69 0.1205
R725 E_REGEN_CLK.n70 E_REGEN_CLK.n64 0.1205
R726 E_REGEN_CLK.n76 E_REGEN_CLK.n64 0.1205
R727 E_REGEN_CLK.n77 E_REGEN_CLK.n76 0.1205
R728 E_REGEN_CLK.n78 E_REGEN_CLK.n77 0.1205
R729 E_REGEN_CLK.n78 E_REGEN_CLK.n61 0.1205
R730 E_REGEN_CLK.n58 E_REGEN_CLK.n46 0.0485
R731 E_REGEN_CLK.n58 E_REGEN_CLK.n57 0.0485
R732 O_REGEN_CLKB.t7 O_REGEN_CLKB.n32 127.788
R733 O_REGEN_CLKB.n16 O_REGEN_CLKB.t15 127.788
R734 O_REGEN_CLKB.t8 O_REGEN_CLKB.n7 127.788
R735 O_REGEN_CLKB.t0 O_REGEN_CLKB.n21 127.737
R736 O_REGEN_CLKB.n32 O_REGEN_CLKB.t6 127.668
R737 O_REGEN_CLKB.n31 O_REGEN_CLKB.t5 127.668
R738 O_REGEN_CLKB.n30 O_REGEN_CLKB.t4 127.668
R739 O_REGEN_CLKB.n29 O_REGEN_CLKB.t3 127.668
R740 O_REGEN_CLKB.n28 O_REGEN_CLKB.t2 127.668
R741 O_REGEN_CLKB.n27 O_REGEN_CLKB.t1 127.668
R742 O_REGEN_CLKB.t13 O_REGEN_CLKB.n14 127.668
R743 O_REGEN_CLKB.t14 O_REGEN_CLKB.n16 127.668
R744 O_REGEN_CLKB.n7 O_REGEN_CLKB.t9 127.668
R745 O_REGEN_CLKB.t10 O_REGEN_CLKB.n3 127.668
R746 O_REGEN_CLKB.n12 O_REGEN_CLKB.t11 127.668
R747 O_REGEN_CLKB.n13 O_REGEN_CLKB.t12 127.668
R748 O_REGEN_CLKB.n33 O_REGEN_CLKB.t7 113.632
R749 O_REGEN_CLKB.n18 O_REGEN_CLKB.t15 113.632
R750 O_REGEN_CLKB.n8 O_REGEN_CLKB.t8 113.632
R751 O_REGEN_CLKB.n22 O_REGEN_CLKB.t0 109.174
R752 O_REGEN_CLKB.t6 O_REGEN_CLKB.n26 109.174
R753 O_REGEN_CLKB.n35 O_REGEN_CLKB.t5 109.174
R754 O_REGEN_CLKB.n36 O_REGEN_CLKB.t4 109.174
R755 O_REGEN_CLKB.n37 O_REGEN_CLKB.t3 109.174
R756 O_REGEN_CLKB.n38 O_REGEN_CLKB.t2 109.174
R757 O_REGEN_CLKB.n39 O_REGEN_CLKB.t1 109.174
R758 O_REGEN_CLKB.n15 O_REGEN_CLKB.t13 109.174
R759 O_REGEN_CLKB.n17 O_REGEN_CLKB.t14 109.174
R760 O_REGEN_CLKB.n9 O_REGEN_CLKB.t9 109.174
R761 O_REGEN_CLKB.n10 O_REGEN_CLKB.t10 109.174
R762 O_REGEN_CLKB.t11 O_REGEN_CLKB.n11 109.174
R763 O_REGEN_CLKB.t12 O_REGEN_CLKB.n2 109.174
R764 O_REGEN_CLKB.n43 O_REGEN_CLKB.n20 24.2273
R765 O_REGEN_CLKB.n41 O_REGEN_CLKB.n22 18.5636
R766 O_REGEN_CLKB.n35 O_REGEN_CLKB.n34 18.4942
R767 O_REGEN_CLKB.n36 O_REGEN_CLKB.n25 18.4942
R768 O_REGEN_CLKB.n37 O_REGEN_CLKB.n24 18.4942
R769 O_REGEN_CLKB.n38 O_REGEN_CLKB.n23 18.4942
R770 O_REGEN_CLKB.n40 O_REGEN_CLKB.n39 18.4942
R771 O_REGEN_CLKB.n15 O_REGEN_CLKB.n1 18.4942
R772 O_REGEN_CLKB.n10 O_REGEN_CLKB.n6 18.4942
R773 O_REGEN_CLKB.n11 O_REGEN_CLKB.n5 18.4942
R774 O_REGEN_CLKB.n4 O_REGEN_CLKB.n2 18.4942
R775 O_REGEN_CLKB O_REGEN_CLKB.n43 16.7683
R776 O_REGEN_CLKB.n43 O_REGEN_CLKB.n42 14.0534
R777 O_REGEN_CLKB.n36 O_REGEN_CLKB.n35 11.6805
R778 O_REGEN_CLKB.n35 O_REGEN_CLKB.n26 11.6805
R779 O_REGEN_CLKB.n37 O_REGEN_CLKB.n36 11.6805
R780 O_REGEN_CLKB.n38 O_REGEN_CLKB.n37 11.6805
R781 O_REGEN_CLKB.n39 O_REGEN_CLKB.n38 11.6805
R782 O_REGEN_CLKB.n39 O_REGEN_CLKB.n22 11.6805
R783 O_REGEN_CLKB.n17 O_REGEN_CLKB.n15 11.6805
R784 O_REGEN_CLKB.n10 O_REGEN_CLKB.n9 11.6805
R785 O_REGEN_CLKB.n11 O_REGEN_CLKB.n10 11.6805
R786 O_REGEN_CLKB.n11 O_REGEN_CLKB.n2 11.6805
R787 O_REGEN_CLKB.n15 O_REGEN_CLKB.n2 11.6805
R788 O_REGEN_CLKB.n42 O_REGEN_CLKB.n21 10.8396
R789 O_REGEN_CLKB.n20 O_REGEN_CLKB.n0 10.8396
R790 O_REGEN_CLKB.n42 O_REGEN_CLKB.n41 9.0005
R791 O_REGEN_CLKB.n20 O_REGEN_CLKB.n19 9.0005
R792 O_REGEN_CLKB.n34 O_REGEN_CLKB.n33 7.17687
R793 O_REGEN_CLKB.n8 O_REGEN_CLKB.n6 7.17687
R794 O_REGEN_CLKB.n19 O_REGEN_CLKB.n18 7.10487
R795 O_REGEN_CLKB.n33 O_REGEN_CLKB.n26 4.42851
R796 O_REGEN_CLKB.n18 O_REGEN_CLKB.n17 4.42851
R797 O_REGEN_CLKB.n9 O_REGEN_CLKB.n8 4.42851
R798 O_REGEN_CLKB.n32 O_REGEN_CLKB.n31 0.1205
R799 O_REGEN_CLKB.n31 O_REGEN_CLKB.n30 0.1205
R800 O_REGEN_CLKB.n30 O_REGEN_CLKB.n29 0.1205
R801 O_REGEN_CLKB.n29 O_REGEN_CLKB.n28 0.1205
R802 O_REGEN_CLKB.n28 O_REGEN_CLKB.n27 0.1205
R803 O_REGEN_CLKB.n34 O_REGEN_CLKB.n25 0.1205
R804 O_REGEN_CLKB.n25 O_REGEN_CLKB.n24 0.1205
R805 O_REGEN_CLKB.n24 O_REGEN_CLKB.n23 0.1205
R806 O_REGEN_CLKB.n40 O_REGEN_CLKB.n23 0.1205
R807 O_REGEN_CLKB.n4 O_REGEN_CLKB.n1 0.1205
R808 O_REGEN_CLKB.n5 O_REGEN_CLKB.n4 0.1205
R809 O_REGEN_CLKB.n6 O_REGEN_CLKB.n5 0.1205
R810 O_REGEN_CLKB.n14 O_REGEN_CLKB.n13 0.1205
R811 O_REGEN_CLKB.n13 O_REGEN_CLKB.n12 0.1205
R812 O_REGEN_CLKB.n12 O_REGEN_CLKB.n3 0.1205
R813 O_REGEN_CLKB.n7 O_REGEN_CLKB.n3 0.1205
R814 O_REGEN_CLKB.n27 O_REGEN_CLKB.n21 0.0485
R815 O_REGEN_CLKB.n41 O_REGEN_CLKB.n40 0.0485
R816 O_REGEN_CLKB.n19 O_REGEN_CLKB.n1 0.0485
R817 O_REGEN_CLKB.n14 O_REGEN_CLKB.n0 0.0485
R818 O_REGEN_CLKB.n16 O_REGEN_CLKB.n0 0.0485
R819 E_REGEN_CLKB.t7 E_REGEN_CLKB.n11 127.788
R820 E_REGEN_CLKB.n3 E_REGEN_CLKB.t0 127.788
R821 E_REGEN_CLKB.t8 E_REGEN_CLKB.n30 127.788
R822 E_REGEN_CLKB.t15 E_REGEN_CLKB.n21 127.737
R823 E_REGEN_CLKB.t1 E_REGEN_CLKB.n3 127.668
R824 E_REGEN_CLKB.n11 E_REGEN_CLKB.t6 127.668
R825 E_REGEN_CLKB.n10 E_REGEN_CLKB.t5 127.668
R826 E_REGEN_CLKB.n9 E_REGEN_CLKB.t4 127.668
R827 E_REGEN_CLKB.n8 E_REGEN_CLKB.t3 127.668
R828 E_REGEN_CLKB.n7 E_REGEN_CLKB.t2 127.668
R829 E_REGEN_CLKB.t14 E_REGEN_CLKB.n38 127.668
R830 E_REGEN_CLKB.n30 E_REGEN_CLKB.t9 127.668
R831 E_REGEN_CLKB.n29 E_REGEN_CLKB.t10 127.668
R832 E_REGEN_CLKB.t11 E_REGEN_CLKB.n24 127.668
R833 E_REGEN_CLKB.n36 E_REGEN_CLKB.t12 127.668
R834 E_REGEN_CLKB.n37 E_REGEN_CLKB.t13 127.668
R835 E_REGEN_CLKB.n12 E_REGEN_CLKB.t7 113.632
R836 E_REGEN_CLKB.t0 E_REGEN_CLKB.n1 113.632
R837 E_REGEN_CLKB.n31 E_REGEN_CLKB.t8 113.632
R838 E_REGEN_CLKB.n4 E_REGEN_CLKB.t1 109.174
R839 E_REGEN_CLKB.t6 E_REGEN_CLKB.n6 109.174
R840 E_REGEN_CLKB.n14 E_REGEN_CLKB.t5 109.174
R841 E_REGEN_CLKB.n15 E_REGEN_CLKB.t4 109.174
R842 E_REGEN_CLKB.n16 E_REGEN_CLKB.t3 109.174
R843 E_REGEN_CLKB.n17 E_REGEN_CLKB.t2 109.174
R844 E_REGEN_CLKB.n39 E_REGEN_CLKB.t14 109.174
R845 E_REGEN_CLKB.n40 E_REGEN_CLKB.t15 109.174
R846 E_REGEN_CLKB.n32 E_REGEN_CLKB.t9 109.174
R847 E_REGEN_CLKB.n33 E_REGEN_CLKB.t10 109.174
R848 E_REGEN_CLKB.n34 E_REGEN_CLKB.t11 109.174
R849 E_REGEN_CLKB.t12 E_REGEN_CLKB.n35 109.174
R850 E_REGEN_CLKB.t13 E_REGEN_CLKB.n23 109.174
R851 E_REGEN_CLKB.n43 E_REGEN_CLKB.n20 24.2273
R852 E_REGEN_CLKB.n41 E_REGEN_CLKB.n40 18.5636
R853 E_REGEN_CLKB.n14 E_REGEN_CLKB.n13 18.4942
R854 E_REGEN_CLKB.n15 E_REGEN_CLKB.n5 18.4942
R855 E_REGEN_CLKB.n16 E_REGEN_CLKB.n2 18.4942
R856 E_REGEN_CLKB.n18 E_REGEN_CLKB.n17 18.4942
R857 E_REGEN_CLKB.n39 E_REGEN_CLKB.n22 18.4942
R858 E_REGEN_CLKB.n33 E_REGEN_CLKB.n28 18.4942
R859 E_REGEN_CLKB.n34 E_REGEN_CLKB.n27 18.4942
R860 E_REGEN_CLKB.n35 E_REGEN_CLKB.n26 18.4942
R861 E_REGEN_CLKB.n25 E_REGEN_CLKB.n23 18.4942
R862 E_REGEN_CLKB E_REGEN_CLKB.n43 16.7683
R863 E_REGEN_CLKB.n43 E_REGEN_CLKB.n42 14.0534
R864 E_REGEN_CLKB.n15 E_REGEN_CLKB.n14 11.6805
R865 E_REGEN_CLKB.n14 E_REGEN_CLKB.n6 11.6805
R866 E_REGEN_CLKB.n16 E_REGEN_CLKB.n15 11.6805
R867 E_REGEN_CLKB.n17 E_REGEN_CLKB.n16 11.6805
R868 E_REGEN_CLKB.n17 E_REGEN_CLKB.n4 11.6805
R869 E_REGEN_CLKB.n40 E_REGEN_CLKB.n39 11.6805
R870 E_REGEN_CLKB.n33 E_REGEN_CLKB.n32 11.6805
R871 E_REGEN_CLKB.n34 E_REGEN_CLKB.n33 11.6805
R872 E_REGEN_CLKB.n35 E_REGEN_CLKB.n34 11.6805
R873 E_REGEN_CLKB.n35 E_REGEN_CLKB.n23 11.6805
R874 E_REGEN_CLKB.n39 E_REGEN_CLKB.n23 11.6805
R875 E_REGEN_CLKB.n20 E_REGEN_CLKB.n0 10.8396
R876 E_REGEN_CLKB.n42 E_REGEN_CLKB.n21 10.8396
R877 E_REGEN_CLKB.n20 E_REGEN_CLKB.n19 9.0005
R878 E_REGEN_CLKB.n42 E_REGEN_CLKB.n41 9.0005
R879 E_REGEN_CLKB.n13 E_REGEN_CLKB.n12 7.17687
R880 E_REGEN_CLKB.n31 E_REGEN_CLKB.n28 7.17687
R881 E_REGEN_CLKB.n19 E_REGEN_CLKB.n1 7.10487
R882 E_REGEN_CLKB.n4 E_REGEN_CLKB.n1 4.42851
R883 E_REGEN_CLKB.n12 E_REGEN_CLKB.n6 4.42851
R884 E_REGEN_CLKB.n32 E_REGEN_CLKB.n31 4.42851
R885 E_REGEN_CLKB.n11 E_REGEN_CLKB.n10 0.1205
R886 E_REGEN_CLKB.n10 E_REGEN_CLKB.n9 0.1205
R887 E_REGEN_CLKB.n9 E_REGEN_CLKB.n8 0.1205
R888 E_REGEN_CLKB.n8 E_REGEN_CLKB.n7 0.1205
R889 E_REGEN_CLKB.n13 E_REGEN_CLKB.n5 0.1205
R890 E_REGEN_CLKB.n5 E_REGEN_CLKB.n2 0.1205
R891 E_REGEN_CLKB.n18 E_REGEN_CLKB.n2 0.1205
R892 E_REGEN_CLKB.n25 E_REGEN_CLKB.n22 0.1205
R893 E_REGEN_CLKB.n26 E_REGEN_CLKB.n25 0.1205
R894 E_REGEN_CLKB.n27 E_REGEN_CLKB.n26 0.1205
R895 E_REGEN_CLKB.n28 E_REGEN_CLKB.n27 0.1205
R896 E_REGEN_CLKB.n38 E_REGEN_CLKB.n37 0.1205
R897 E_REGEN_CLKB.n37 E_REGEN_CLKB.n36 0.1205
R898 E_REGEN_CLKB.n36 E_REGEN_CLKB.n24 0.1205
R899 E_REGEN_CLKB.n29 E_REGEN_CLKB.n24 0.1205
R900 E_REGEN_CLKB.n30 E_REGEN_CLKB.n29 0.1205
R901 E_REGEN_CLKB.n3 E_REGEN_CLKB.n0 0.0485
R902 E_REGEN_CLKB.n7 E_REGEN_CLKB.n0 0.0485
R903 E_REGEN_CLKB.n19 E_REGEN_CLKB.n18 0.0485
R904 E_REGEN_CLKB.n41 E_REGEN_CLKB.n22 0.0485
R905 E_REGEN_CLKB.n38 E_REGEN_CLKB.n21 0.0485
R906 O_CAPTURE_CLK.n14 O_CAPTURE_CLK.t8 113.632
R907 O_CAPTURE_CLK.n18 O_CAPTURE_CLK.t15 113.632
R908 O_CAPTURE_CLK.n5 O_CAPTURE_CLK.t7 113.632
R909 O_CAPTURE_CLK.n23 O_CAPTURE_CLK.t9 109.174
R910 O_CAPTURE_CLK.n24 O_CAPTURE_CLK.t10 109.174
R911 O_CAPTURE_CLK.n22 O_CAPTURE_CLK.t11 109.174
R912 O_CAPTURE_CLK.n21 O_CAPTURE_CLK.t12 109.174
R913 O_CAPTURE_CLK.n16 O_CAPTURE_CLK.t13 109.174
R914 O_CAPTURE_CLK.n17 O_CAPTURE_CLK.t14 109.174
R915 O_CAPTURE_CLK.n0 O_CAPTURE_CLK.t0 109.174
R916 O_CAPTURE_CLK.n11 O_CAPTURE_CLK.t1 109.174
R917 O_CAPTURE_CLK.n6 O_CAPTURE_CLK.t6 109.174
R918 O_CAPTURE_CLK.n7 O_CAPTURE_CLK.t5 109.174
R919 O_CAPTURE_CLK.n8 O_CAPTURE_CLK.t4 109.174
R920 O_CAPTURE_CLK.n9 O_CAPTURE_CLK.t3 109.174
R921 O_CAPTURE_CLK.n10 O_CAPTURE_CLK.t2 109.174
R922 O_CAPTURE_CLK.n27 O_CAPTURE_CLK.n13 19.4679
R923 O_CAPTURE_CLK O_CAPTURE_CLK.n27 18.7296
R924 O_CAPTURE_CLK.n13 O_CAPTURE_CLK.n0 18.5636
R925 O_CAPTURE_CLK.n25 O_CAPTURE_CLK.n24 18.4942
R926 O_CAPTURE_CLK.n22 O_CAPTURE_CLK.n15 18.4942
R927 O_CAPTURE_CLK.n21 O_CAPTURE_CLK.n20 18.4942
R928 O_CAPTURE_CLK.n19 O_CAPTURE_CLK.n16 18.4942
R929 O_CAPTURE_CLK.n12 O_CAPTURE_CLK.n11 18.4942
R930 O_CAPTURE_CLK.n7 O_CAPTURE_CLK.n4 18.4942
R931 O_CAPTURE_CLK.n8 O_CAPTURE_CLK.n3 18.4942
R932 O_CAPTURE_CLK.n9 O_CAPTURE_CLK.n2 18.4942
R933 O_CAPTURE_CLK.n10 O_CAPTURE_CLK.n1 18.4942
R934 O_CAPTURE_CLK.n27 O_CAPTURE_CLK.n26 14.9288
R935 O_CAPTURE_CLK.n24 O_CAPTURE_CLK.n23 11.6805
R936 O_CAPTURE_CLK.n24 O_CAPTURE_CLK.n22 11.6805
R937 O_CAPTURE_CLK.n22 O_CAPTURE_CLK.n21 11.6805
R938 O_CAPTURE_CLK.n21 O_CAPTURE_CLK.n16 11.6805
R939 O_CAPTURE_CLK.n17 O_CAPTURE_CLK.n16 11.6805
R940 O_CAPTURE_CLK.n11 O_CAPTURE_CLK.n0 11.6805
R941 O_CAPTURE_CLK.n7 O_CAPTURE_CLK.n6 11.6805
R942 O_CAPTURE_CLK.n8 O_CAPTURE_CLK.n7 11.6805
R943 O_CAPTURE_CLK.n9 O_CAPTURE_CLK.n8 11.6805
R944 O_CAPTURE_CLK.n10 O_CAPTURE_CLK.n9 11.6805
R945 O_CAPTURE_CLK.n11 O_CAPTURE_CLK.n10 11.6805
R946 O_CAPTURE_CLK.n19 O_CAPTURE_CLK.n18 7.17687
R947 O_CAPTURE_CLK.n5 O_CAPTURE_CLK.n4 7.17687
R948 O_CAPTURE_CLK.n26 O_CAPTURE_CLK.n14 7.10487
R949 O_CAPTURE_CLK.n23 O_CAPTURE_CLK.n14 4.42851
R950 O_CAPTURE_CLK.n18 O_CAPTURE_CLK.n17 4.42851
R951 O_CAPTURE_CLK.n6 O_CAPTURE_CLK.n5 4.42851
R952 O_CAPTURE_CLK.n20 O_CAPTURE_CLK.n19 0.1205
R953 O_CAPTURE_CLK.n20 O_CAPTURE_CLK.n15 0.1205
R954 O_CAPTURE_CLK.n25 O_CAPTURE_CLK.n15 0.1205
R955 O_CAPTURE_CLK.n4 O_CAPTURE_CLK.n3 0.1205
R956 O_CAPTURE_CLK.n3 O_CAPTURE_CLK.n2 0.1205
R957 O_CAPTURE_CLK.n2 O_CAPTURE_CLK.n1 0.1205
R958 O_CAPTURE_CLK.n12 O_CAPTURE_CLK.n1 0.1205
R959 O_CAPTURE_CLK.n26 O_CAPTURE_CLK.n25 0.0485
R960 O_CAPTURE_CLK.n13 O_CAPTURE_CLK.n12 0.0485
R961 E_CAPTURE_CLK.n5 E_CAPTURE_CLK.t7 113.632
R962 E_CAPTURE_CLK.n14 E_CAPTURE_CLK.t8 113.632
R963 E_CAPTURE_CLK.n18 E_CAPTURE_CLK.t15 113.632
R964 E_CAPTURE_CLK.n0 E_CAPTURE_CLK.t0 109.174
R965 E_CAPTURE_CLK.n11 E_CAPTURE_CLK.t1 109.174
R966 E_CAPTURE_CLK.n6 E_CAPTURE_CLK.t6 109.174
R967 E_CAPTURE_CLK.n7 E_CAPTURE_CLK.t5 109.174
R968 E_CAPTURE_CLK.n8 E_CAPTURE_CLK.t4 109.174
R969 E_CAPTURE_CLK.n9 E_CAPTURE_CLK.t3 109.174
R970 E_CAPTURE_CLK.n10 E_CAPTURE_CLK.t2 109.174
R971 E_CAPTURE_CLK.n23 E_CAPTURE_CLK.t9 109.174
R972 E_CAPTURE_CLK.n24 E_CAPTURE_CLK.t10 109.174
R973 E_CAPTURE_CLK.n22 E_CAPTURE_CLK.t11 109.174
R974 E_CAPTURE_CLK.n21 E_CAPTURE_CLK.t12 109.174
R975 E_CAPTURE_CLK.n16 E_CAPTURE_CLK.t13 109.174
R976 E_CAPTURE_CLK.n17 E_CAPTURE_CLK.t14 109.174
R977 E_CAPTURE_CLK E_CAPTURE_CLK.n27 19.486
R978 E_CAPTURE_CLK.n13 E_CAPTURE_CLK.n0 18.5636
R979 E_CAPTURE_CLK.n12 E_CAPTURE_CLK.n11 18.4942
R980 E_CAPTURE_CLK.n7 E_CAPTURE_CLK.n4 18.4942
R981 E_CAPTURE_CLK.n8 E_CAPTURE_CLK.n3 18.4942
R982 E_CAPTURE_CLK.n9 E_CAPTURE_CLK.n2 18.4942
R983 E_CAPTURE_CLK.n10 E_CAPTURE_CLK.n1 18.4942
R984 E_CAPTURE_CLK.n25 E_CAPTURE_CLK.n24 18.4942
R985 E_CAPTURE_CLK.n22 E_CAPTURE_CLK.n15 18.4942
R986 E_CAPTURE_CLK.n21 E_CAPTURE_CLK.n20 18.4942
R987 E_CAPTURE_CLK.n19 E_CAPTURE_CLK.n16 18.4942
R988 E_CAPTURE_CLK.n27 E_CAPTURE_CLK.n13 18.4114
R989 E_CAPTURE_CLK.n27 E_CAPTURE_CLK.n26 13.5592
R990 E_CAPTURE_CLK.n11 E_CAPTURE_CLK.n0 11.6805
R991 E_CAPTURE_CLK.n7 E_CAPTURE_CLK.n6 11.6805
R992 E_CAPTURE_CLK.n8 E_CAPTURE_CLK.n7 11.6805
R993 E_CAPTURE_CLK.n9 E_CAPTURE_CLK.n8 11.6805
R994 E_CAPTURE_CLK.n10 E_CAPTURE_CLK.n9 11.6805
R995 E_CAPTURE_CLK.n11 E_CAPTURE_CLK.n10 11.6805
R996 E_CAPTURE_CLK.n24 E_CAPTURE_CLK.n23 11.6805
R997 E_CAPTURE_CLK.n24 E_CAPTURE_CLK.n22 11.6805
R998 E_CAPTURE_CLK.n22 E_CAPTURE_CLK.n21 11.6805
R999 E_CAPTURE_CLK.n21 E_CAPTURE_CLK.n16 11.6805
R1000 E_CAPTURE_CLK.n17 E_CAPTURE_CLK.n16 11.6805
R1001 E_CAPTURE_CLK.n5 E_CAPTURE_CLK.n4 7.17687
R1002 E_CAPTURE_CLK.n19 E_CAPTURE_CLK.n18 7.17687
R1003 E_CAPTURE_CLK.n26 E_CAPTURE_CLK.n14 7.10487
R1004 E_CAPTURE_CLK.n6 E_CAPTURE_CLK.n5 4.42851
R1005 E_CAPTURE_CLK.n23 E_CAPTURE_CLK.n14 4.42851
R1006 E_CAPTURE_CLK.n18 E_CAPTURE_CLK.n17 4.42851
R1007 E_CAPTURE_CLK.n4 E_CAPTURE_CLK.n3 0.1205
R1008 E_CAPTURE_CLK.n3 E_CAPTURE_CLK.n2 0.1205
R1009 E_CAPTURE_CLK.n2 E_CAPTURE_CLK.n1 0.1205
R1010 E_CAPTURE_CLK.n12 E_CAPTURE_CLK.n1 0.1205
R1011 E_CAPTURE_CLK.n20 E_CAPTURE_CLK.n19 0.1205
R1012 E_CAPTURE_CLK.n20 E_CAPTURE_CLK.n15 0.1205
R1013 E_CAPTURE_CLK.n25 E_CAPTURE_CLK.n15 0.1205
R1014 E_CAPTURE_CLK.n13 E_CAPTURE_CLK.n12 0.0485
R1015 E_CAPTURE_CLK.n26 E_CAPTURE_CLK.n25 0.0485
R1016 FE_O_N.n16 FE_O_N.t17 113.632
R1017 FE_O_N.n13 FE_O_N.t14 113.632
R1018 FE_O_N.n6 FE_O_N.t18 113.632
R1019 FE_O_N.n2 FE_O_N.t25 113.632
R1020 FE_O_N.n14 FE_O_N.t15 109.174
R1021 FE_O_N.n15 FE_O_N.t16 109.174
R1022 FE_O_N.n7 FE_O_N.t19 109.174
R1023 FE_O_N.n8 FE_O_N.t20 109.174
R1024 FE_O_N.n9 FE_O_N.t21 109.174
R1025 FE_O_N.n10 FE_O_N.t22 109.174
R1026 FE_O_N.n4 FE_O_N.t23 109.174
R1027 FE_O_N.n3 FE_O_N.t24 109.174
R1028 FE_O_N.n32 FE_O_N.n18 74.8513
R1029 FE_O_N.n8 FE_O_N.n5 18.4942
R1030 FE_O_N.n9 FE_O_N.n0 18.4942
R1031 FE_O_N.n11 FE_O_N.n10 18.4942
R1032 FE_O_N.n4 FE_O_N.n1 18.4942
R1033 FE_O_N.n18 FE_O_N.n12 14.8701
R1034 FE_O_N.n15 FE_O_N.n14 11.6805
R1035 FE_O_N.n8 FE_O_N.n7 11.6805
R1036 FE_O_N.n9 FE_O_N.n8 11.6805
R1037 FE_O_N.n10 FE_O_N.n9 11.6805
R1038 FE_O_N.n10 FE_O_N.n4 11.6805
R1039 FE_O_N.n4 FE_O_N.n3 11.6805
R1040 FE_O_N.n32 FE_O_N.n31 11.3092
R1041 FE_O_N.n31 FE_O_N.n30 9.42986
R1042 FE_O_N.n18 FE_O_N.n17 9.0005
R1043 FE_O_N.n6 FE_O_N.n5 7.17687
R1044 FE_O_N.n2 FE_O_N.n1 7.17687
R1045 FE_O_N.n17 FE_O_N.n13 7.10487
R1046 FE_O_N.n17 FE_O_N.n16 7.10487
R1047 FE_O_N.n31 FE_O_N.n25 7.01407
R1048 FE_O_N.n27 FE_O_N.t0 5.7796
R1049 FE_O_N.n20 FE_O_N.t6 5.73764
R1050 FE_O_N.n24 FE_O_N.t5 5.73764
R1051 FE_O_N.n30 FE_O_N.t13 5.59012
R1052 FE_O_N.n27 FE_O_N.n26 5.38537
R1053 FE_O_N.n29 FE_O_N.n28 5.38537
R1054 FE_O_N.n20 FE_O_N.n19 5.32067
R1055 FE_O_N.n22 FE_O_N.n21 5.32067
R1056 FE_O_N.n24 FE_O_N.n23 5.32067
R1057 FE_O_N.n14 FE_O_N.n13 4.42851
R1058 FE_O_N.n16 FE_O_N.n15 4.42851
R1059 FE_O_N.n7 FE_O_N.n6 4.42851
R1060 FE_O_N.n3 FE_O_N.n2 4.42851
R1061 FE_O_N.n19 FE_O_N.t8 0.228
R1062 FE_O_N.n19 FE_O_N.t7 0.228
R1063 FE_O_N.n21 FE_O_N.t2 0.228
R1064 FE_O_N.n21 FE_O_N.t9 0.228
R1065 FE_O_N.n23 FE_O_N.t4 0.228
R1066 FE_O_N.n23 FE_O_N.t3 0.228
R1067 FE_O_N.n26 FE_O_N.t10 0.20525
R1068 FE_O_N.n26 FE_O_N.t1 0.20525
R1069 FE_O_N.n28 FE_O_N.t12 0.20525
R1070 FE_O_N.n28 FE_O_N.t11 0.20525
R1071 FE_O_N.n30 FE_O_N.n29 0.189974
R1072 FE_O_N.n29 FE_O_N.n27 0.189974
R1073 FE_O_N.n22 FE_O_N.n20 0.189974
R1074 FE_O_N.n5 FE_O_N.n0 0.1205
R1075 FE_O_N.n11 FE_O_N.n1 0.1205
R1076 FE_O_N.n25 FE_O_N.n24 0.0952368
R1077 FE_O_N.n25 FE_O_N.n22 0.0952368
R1078 FE_O_N.n12 FE_O_N.n0 0.0485
R1079 FE_O_N.n12 FE_O_N.n11 0.0485
R1080 FE_O_N FE_O_N.n32 0.0205
R1081 FE_O_P.n16 FE_O_P.t17 113.632
R1082 FE_O_P.n13 FE_O_P.t14 113.632
R1083 FE_O_P.n6 FE_O_P.t18 113.632
R1084 FE_O_P.n2 FE_O_P.t25 113.632
R1085 FE_O_P.n14 FE_O_P.t15 109.174
R1086 FE_O_P.n15 FE_O_P.t16 109.174
R1087 FE_O_P.n7 FE_O_P.t19 109.174
R1088 FE_O_P.n8 FE_O_P.t20 109.174
R1089 FE_O_P.n9 FE_O_P.t21 109.174
R1090 FE_O_P.n10 FE_O_P.t22 109.174
R1091 FE_O_P.n4 FE_O_P.t23 109.174
R1092 FE_O_P.n3 FE_O_P.t24 109.174
R1093 FE_O_P FE_O_P.n18 76.9565
R1094 FE_O_P.n8 FE_O_P.n5 18.4942
R1095 FE_O_P.n9 FE_O_P.n0 18.4942
R1096 FE_O_P.n11 FE_O_P.n10 18.4942
R1097 FE_O_P.n4 FE_O_P.n1 18.4942
R1098 FE_O_P.n18 FE_O_P.n12 14.8701
R1099 FE_O_P.n15 FE_O_P.n14 11.6805
R1100 FE_O_P.n8 FE_O_P.n7 11.6805
R1101 FE_O_P.n9 FE_O_P.n8 11.6805
R1102 FE_O_P.n10 FE_O_P.n9 11.6805
R1103 FE_O_P.n10 FE_O_P.n4 11.6805
R1104 FE_O_P.n4 FE_O_P.n3 11.6805
R1105 FE_O_P FE_O_P.n31 11.0162
R1106 FE_O_P.n18 FE_O_P.n17 9.0005
R1107 FE_O_P.n31 FE_O_P.n30 8.81407
R1108 FE_O_P.n31 FE_O_P.n25 7.46407
R1109 FE_O_P.n6 FE_O_P.n5 7.17687
R1110 FE_O_P.n2 FE_O_P.n1 7.17687
R1111 FE_O_P.n17 FE_O_P.n13 7.10487
R1112 FE_O_P.n17 FE_O_P.n16 7.10487
R1113 FE_O_P.n27 FE_O_P.t10 5.7796
R1114 FE_O_P.n20 FE_O_P.t11 5.73764
R1115 FE_O_P.n24 FE_O_P.t4 5.73764
R1116 FE_O_P.n30 FE_O_P.t5 5.61381
R1117 FE_O_P.n29 FE_O_P.n28 5.38537
R1118 FE_O_P.n27 FE_O_P.n26 5.38537
R1119 FE_O_P.n20 FE_O_P.n19 5.32067
R1120 FE_O_P.n22 FE_O_P.n21 5.32067
R1121 FE_O_P.n24 FE_O_P.n23 5.32067
R1122 FE_O_P.n14 FE_O_P.n13 4.42851
R1123 FE_O_P.n16 FE_O_P.n15 4.42851
R1124 FE_O_P.n7 FE_O_P.n6 4.42851
R1125 FE_O_P.n3 FE_O_P.n2 4.42851
R1126 FE_O_P.n19 FE_O_P.t13 0.228
R1127 FE_O_P.n19 FE_O_P.t12 0.228
R1128 FE_O_P.n21 FE_O_P.t1 0.228
R1129 FE_O_P.n21 FE_O_P.t0 0.228
R1130 FE_O_P.n23 FE_O_P.t3 0.228
R1131 FE_O_P.n23 FE_O_P.t2 0.228
R1132 FE_O_P.n28 FE_O_P.t7 0.20525
R1133 FE_O_P.n28 FE_O_P.t6 0.20525
R1134 FE_O_P.n26 FE_O_P.t9 0.20525
R1135 FE_O_P.n26 FE_O_P.t8 0.20525
R1136 FE_O_P.n29 FE_O_P.n27 0.189974
R1137 FE_O_P.n22 FE_O_P.n20 0.189974
R1138 FE_O_P.n30 FE_O_P.n29 0.166289
R1139 FE_O_P.n5 FE_O_P.n0 0.1205
R1140 FE_O_P.n11 FE_O_P.n1 0.1205
R1141 FE_O_P.n25 FE_O_P.n24 0.0952368
R1142 FE_O_P.n25 FE_O_P.n22 0.0952368
R1143 FE_O_P.n12 FE_O_P.n0 0.0485
R1144 FE_O_P.n12 FE_O_P.n11 0.0485
R1145 FE_E_P.n16 FE_E_P.t17 113.632
R1146 FE_E_P.n13 FE_E_P.t14 113.632
R1147 FE_E_P.n6 FE_E_P.t18 113.632
R1148 FE_E_P.n2 FE_E_P.t25 113.632
R1149 FE_E_P.n14 FE_E_P.t15 109.174
R1150 FE_E_P.n15 FE_E_P.t16 109.174
R1151 FE_E_P.n7 FE_E_P.t19 109.174
R1152 FE_E_P.n8 FE_E_P.t20 109.174
R1153 FE_E_P.n9 FE_E_P.t21 109.174
R1154 FE_E_P.n10 FE_E_P.t22 109.174
R1155 FE_E_P.n4 FE_E_P.t23 109.174
R1156 FE_E_P.n3 FE_E_P.t24 109.174
R1157 FE_E_P FE_E_P.n18 77.1792
R1158 FE_E_P.n8 FE_E_P.n5 18.4942
R1159 FE_E_P.n9 FE_E_P.n0 18.4942
R1160 FE_E_P.n11 FE_E_P.n10 18.4942
R1161 FE_E_P.n4 FE_E_P.n1 18.4942
R1162 FE_E_P.n18 FE_E_P.n12 14.8701
R1163 FE_E_P.n15 FE_E_P.n14 11.6805
R1164 FE_E_P.n8 FE_E_P.n7 11.6805
R1165 FE_E_P.n9 FE_E_P.n8 11.6805
R1166 FE_E_P.n10 FE_E_P.n9 11.6805
R1167 FE_E_P.n10 FE_E_P.n4 11.6805
R1168 FE_E_P.n4 FE_E_P.n3 11.6805
R1169 FE_E_P FE_E_P.n31 11.3292
R1170 FE_E_P.n31 FE_E_P.n30 9.42986
R1171 FE_E_P.n18 FE_E_P.n17 9.0005
R1172 FE_E_P.n6 FE_E_P.n5 7.17687
R1173 FE_E_P.n2 FE_E_P.n1 7.17687
R1174 FE_E_P.n17 FE_E_P.n13 7.10487
R1175 FE_E_P.n17 FE_E_P.n16 7.10487
R1176 FE_E_P.n31 FE_E_P.n25 7.01407
R1177 FE_E_P.n27 FE_E_P.t7 5.7796
R1178 FE_E_P.n20 FE_E_P.t8 5.73764
R1179 FE_E_P.n22 FE_E_P.t1 5.73764
R1180 FE_E_P.n30 FE_E_P.t2 5.59012
R1181 FE_E_P.n29 FE_E_P.n28 5.38537
R1182 FE_E_P.n27 FE_E_P.n26 5.38537
R1183 FE_E_P.n20 FE_E_P.n19 5.32067
R1184 FE_E_P.n24 FE_E_P.n23 5.32067
R1185 FE_E_P.n22 FE_E_P.n21 5.32067
R1186 FE_E_P.n14 FE_E_P.n13 4.42851
R1187 FE_E_P.n16 FE_E_P.n15 4.42851
R1188 FE_E_P.n7 FE_E_P.n6 4.42851
R1189 FE_E_P.n3 FE_E_P.n2 4.42851
R1190 FE_E_P.n19 FE_E_P.t10 0.228
R1191 FE_E_P.n19 FE_E_P.t9 0.228
R1192 FE_E_P.n23 FE_E_P.t12 0.228
R1193 FE_E_P.n23 FE_E_P.t11 0.228
R1194 FE_E_P.n21 FE_E_P.t0 0.228
R1195 FE_E_P.n21 FE_E_P.t13 0.228
R1196 FE_E_P.n28 FE_E_P.t4 0.20525
R1197 FE_E_P.n28 FE_E_P.t3 0.20525
R1198 FE_E_P.n26 FE_E_P.t6 0.20525
R1199 FE_E_P.n26 FE_E_P.t5 0.20525
R1200 FE_E_P.n29 FE_E_P.n27 0.189974
R1201 FE_E_P.n30 FE_E_P.n29 0.189974
R1202 FE_E_P.n24 FE_E_P.n22 0.189974
R1203 FE_E_P.n5 FE_E_P.n0 0.1205
R1204 FE_E_P.n11 FE_E_P.n1 0.1205
R1205 FE_E_P.n25 FE_E_P.n24 0.0952368
R1206 FE_E_P.n25 FE_E_P.n20 0.0952368
R1207 FE_E_P.n12 FE_E_P.n0 0.0485
R1208 FE_E_P.n12 FE_E_P.n11 0.0485
R1209 FE_E_N.n16 FE_E_N.t17 113.632
R1210 FE_E_N.n13 FE_E_N.t14 113.632
R1211 FE_E_N.n6 FE_E_N.t18 113.632
R1212 FE_E_N.n2 FE_E_N.t25 113.632
R1213 FE_E_N.n14 FE_E_N.t15 109.174
R1214 FE_E_N.n15 FE_E_N.t16 109.174
R1215 FE_E_N.n7 FE_E_N.t19 109.174
R1216 FE_E_N.n8 FE_E_N.t20 109.174
R1217 FE_E_N.n9 FE_E_N.t21 109.174
R1218 FE_E_N.n10 FE_E_N.t22 109.174
R1219 FE_E_N.n4 FE_E_N.t23 109.174
R1220 FE_E_N.n3 FE_E_N.t24 109.174
R1221 FE_E_N.n32 FE_E_N.n18 74.6287
R1222 FE_E_N.n8 FE_E_N.n5 18.4942
R1223 FE_E_N.n9 FE_E_N.n0 18.4942
R1224 FE_E_N.n11 FE_E_N.n10 18.4942
R1225 FE_E_N.n4 FE_E_N.n1 18.4942
R1226 FE_E_N.n18 FE_E_N.n12 14.8701
R1227 FE_E_N.n15 FE_E_N.n14 11.6805
R1228 FE_E_N.n8 FE_E_N.n7 11.6805
R1229 FE_E_N.n9 FE_E_N.n8 11.6805
R1230 FE_E_N.n10 FE_E_N.n9 11.6805
R1231 FE_E_N.n10 FE_E_N.n4 11.6805
R1232 FE_E_N.n4 FE_E_N.n3 11.6805
R1233 FE_E_N.n32 FE_E_N.n31 10.9962
R1234 FE_E_N.n18 FE_E_N.n17 9.0005
R1235 FE_E_N.n31 FE_E_N.n30 8.81407
R1236 FE_E_N.n31 FE_E_N.n25 7.46407
R1237 FE_E_N.n6 FE_E_N.n5 7.17687
R1238 FE_E_N.n2 FE_E_N.n1 7.17687
R1239 FE_E_N.n17 FE_E_N.n13 7.10487
R1240 FE_E_N.n17 FE_E_N.n16 7.10487
R1241 FE_E_N.n27 FE_E_N.t12 5.7796
R1242 FE_E_N.n20 FE_E_N.t4 5.73764
R1243 FE_E_N.n22 FE_E_N.t11 5.73764
R1244 FE_E_N.n30 FE_E_N.t3 5.61381
R1245 FE_E_N.n27 FE_E_N.n26 5.38537
R1246 FE_E_N.n29 FE_E_N.n28 5.38537
R1247 FE_E_N.n20 FE_E_N.n19 5.32067
R1248 FE_E_N.n24 FE_E_N.n23 5.32067
R1249 FE_E_N.n22 FE_E_N.n21 5.32067
R1250 FE_E_N.n14 FE_E_N.n13 4.42851
R1251 FE_E_N.n16 FE_E_N.n15 4.42851
R1252 FE_E_N.n7 FE_E_N.n6 4.42851
R1253 FE_E_N.n3 FE_E_N.n2 4.42851
R1254 FE_E_N.n19 FE_E_N.t6 0.228
R1255 FE_E_N.n19 FE_E_N.t5 0.228
R1256 FE_E_N.n23 FE_E_N.t8 0.228
R1257 FE_E_N.n23 FE_E_N.t7 0.228
R1258 FE_E_N.n21 FE_E_N.t10 0.228
R1259 FE_E_N.n21 FE_E_N.t9 0.228
R1260 FE_E_N.n26 FE_E_N.t0 0.20525
R1261 FE_E_N.n26 FE_E_N.t13 0.20525
R1262 FE_E_N.n28 FE_E_N.t2 0.20525
R1263 FE_E_N.n28 FE_E_N.t1 0.20525
R1264 FE_E_N.n29 FE_E_N.n27 0.189974
R1265 FE_E_N.n24 FE_E_N.n22 0.189974
R1266 FE_E_N.n30 FE_E_N.n29 0.166289
R1267 FE_E_N.n5 FE_E_N.n0 0.1205
R1268 FE_E_N.n11 FE_E_N.n1 0.1205
R1269 FE_E_N.n25 FE_E_N.n24 0.0952368
R1270 FE_E_N.n25 FE_E_N.n20 0.0952368
R1271 FE_E_N.n12 FE_E_N.n0 0.0485
R1272 FE_E_N.n12 FE_E_N.n11 0.0485
R1273 FE_E_N FE_E_N.n32 0.0205
R1274 ODD_Q.n5 ODD_Q.n2 12.9918
R1275 ODD_Q ODD_Q.n5 10.5466
R1276 ODD_Q.n1 ODD_Q.t1 5.73764
R1277 ODD_Q.n2 ODD_Q.t2 5.6429
R1278 ODD_Q.n4 ODD_Q.t3 5.63749
R1279 ODD_Q.n4 ODD_Q.n3 5.52748
R1280 ODD_Q.n1 ODD_Q.n0 5.32067
R1281 ODD_Q.n5 ODD_Q.n4 4.61789
R1282 ODD_Q.n0 ODD_Q.t6 0.228
R1283 ODD_Q.n0 ODD_Q.t5 0.228
R1284 ODD_Q.n3 ODD_Q.t4 0.20525
R1285 ODD_Q.n3 ODD_Q.t0 0.20525
R1286 ODD_Q.n2 ODD_Q.n1 0.0952368
R1287 ODD_QB ODD_QB.n5 21.5031
R1288 ODD_QB.n5 ODD_QB.n2 12.7179
R1289 ODD_QB.n1 ODD_QB.t1 5.73764
R1290 ODD_QB.n2 ODD_QB.t5 5.6429
R1291 ODD_QB.n4 ODD_QB.t3 5.63749
R1292 ODD_QB.n4 ODD_QB.n3 5.52748
R1293 ODD_QB.n1 ODD_QB.n0 5.32067
R1294 ODD_QB.n5 ODD_QB.n4 4.8918
R1295 ODD_QB.n0 ODD_QB.t6 0.228
R1296 ODD_QB.n0 ODD_QB.t4 0.228
R1297 ODD_QB.n3 ODD_QB.t2 0.20525
R1298 ODD_QB.n3 ODD_QB.t0 0.20525
R1299 ODD_QB.n2 ODD_QB.n1 0.0952368
R1300 EVEN_QB EVEN_QB.n5 20.9553
R1301 EVEN_QB.n5 EVEN_QB.n2 13.1092
R1302 EVEN_QB.n1 EVEN_QB.t6 5.73764
R1303 EVEN_QB.n2 EVEN_QB.t1 5.6429
R1304 EVEN_QB.n4 EVEN_QB.t5 5.63749
R1305 EVEN_QB.n4 EVEN_QB.n3 5.52748
R1306 EVEN_QB.n1 EVEN_QB.n0 5.32067
R1307 EVEN_QB.n5 EVEN_QB.n4 4.5005
R1308 EVEN_QB.n0 EVEN_QB.t3 0.228
R1309 EVEN_QB.n0 EVEN_QB.t4 0.228
R1310 EVEN_QB.n3 EVEN_QB.t0 0.20525
R1311 EVEN_QB.n3 EVEN_QB.t2 0.20525
R1312 EVEN_QB.n2 EVEN_QB.n1 0.0952368
R1313 EVEN_Q.n5 EVEN_Q.n2 13.1092
R1314 EVEN_Q EVEN_Q.n5 11.0553
R1315 EVEN_Q.n1 EVEN_Q.t5 5.73764
R1316 EVEN_Q.n2 EVEN_Q.t6 5.6429
R1317 EVEN_Q.n4 EVEN_Q.t2 5.63749
R1318 EVEN_Q.n4 EVEN_Q.n3 5.52748
R1319 EVEN_Q.n1 EVEN_Q.n0 5.32067
R1320 EVEN_Q.n5 EVEN_Q.n4 4.5005
R1321 EVEN_Q.n0 EVEN_Q.t4 0.228
R1322 EVEN_Q.n0 EVEN_Q.t0 0.228
R1323 EVEN_Q.n3 EVEN_Q.t1 0.20525
R1324 EVEN_Q.n3 EVEN_Q.t3 0.20525
R1325 EVEN_Q.n2 EVEN_Q.n1 0.0952368
R1326 O_CAPTURE_CLKB.n17 O_CAPTURE_CLKB.t0 113.632
R1327 O_CAPTURE_CLKB.n5 O_CAPTURE_CLKB.t8 113.632
R1328 O_CAPTURE_CLKB.n26 O_CAPTURE_CLKB.t7 109.174
R1329 O_CAPTURE_CLKB.n25 O_CAPTURE_CLKB.t6 109.174
R1330 O_CAPTURE_CLKB.n24 O_CAPTURE_CLKB.t5 109.174
R1331 O_CAPTURE_CLKB.n15 O_CAPTURE_CLKB.t4 109.174
R1332 O_CAPTURE_CLKB.n20 O_CAPTURE_CLKB.t3 109.174
R1333 O_CAPTURE_CLKB.n19 O_CAPTURE_CLKB.t2 109.174
R1334 O_CAPTURE_CLKB.n18 O_CAPTURE_CLKB.t1 109.174
R1335 O_CAPTURE_CLKB.n6 O_CAPTURE_CLKB.t9 109.174
R1336 O_CAPTURE_CLKB.n7 O_CAPTURE_CLKB.t10 109.174
R1337 O_CAPTURE_CLKB.n8 O_CAPTURE_CLKB.t11 109.174
R1338 O_CAPTURE_CLKB.n9 O_CAPTURE_CLKB.t12 109.174
R1339 O_CAPTURE_CLKB.n10 O_CAPTURE_CLKB.t13 109.174
R1340 O_CAPTURE_CLKB.n11 O_CAPTURE_CLKB.t14 109.174
R1341 O_CAPTURE_CLKB.n12 O_CAPTURE_CLKB.t15 109.174
R1342 O_CAPTURE_CLKB O_CAPTURE_CLKB.n28 47.0442
R1343 O_CAPTURE_CLKB.n27 O_CAPTURE_CLKB.n26 18.4942
R1344 O_CAPTURE_CLKB.n25 O_CAPTURE_CLKB.n14 18.4942
R1345 O_CAPTURE_CLKB.n24 O_CAPTURE_CLKB.n23 18.4942
R1346 O_CAPTURE_CLKB.n22 O_CAPTURE_CLKB.n15 18.4942
R1347 O_CAPTURE_CLKB.n21 O_CAPTURE_CLKB.n20 18.4942
R1348 O_CAPTURE_CLKB.n19 O_CAPTURE_CLKB.n16 18.4942
R1349 O_CAPTURE_CLKB.n7 O_CAPTURE_CLKB.n4 18.4942
R1350 O_CAPTURE_CLKB.n8 O_CAPTURE_CLKB.n3 18.4942
R1351 O_CAPTURE_CLKB.n9 O_CAPTURE_CLKB.n2 18.4942
R1352 O_CAPTURE_CLKB.n10 O_CAPTURE_CLKB.n1 18.4942
R1353 O_CAPTURE_CLKB.n11 O_CAPTURE_CLKB.n0 18.4942
R1354 O_CAPTURE_CLKB.n13 O_CAPTURE_CLKB.n12 18.4942
R1355 O_CAPTURE_CLKB.n28 O_CAPTURE_CLKB.n13 14.2555
R1356 O_CAPTURE_CLKB.n26 O_CAPTURE_CLKB.n25 11.6805
R1357 O_CAPTURE_CLKB.n25 O_CAPTURE_CLKB.n24 11.6805
R1358 O_CAPTURE_CLKB.n24 O_CAPTURE_CLKB.n15 11.6805
R1359 O_CAPTURE_CLKB.n20 O_CAPTURE_CLKB.n15 11.6805
R1360 O_CAPTURE_CLKB.n20 O_CAPTURE_CLKB.n19 11.6805
R1361 O_CAPTURE_CLKB.n19 O_CAPTURE_CLKB.n18 11.6805
R1362 O_CAPTURE_CLKB.n7 O_CAPTURE_CLKB.n6 11.6805
R1363 O_CAPTURE_CLKB.n8 O_CAPTURE_CLKB.n7 11.6805
R1364 O_CAPTURE_CLKB.n9 O_CAPTURE_CLKB.n8 11.6805
R1365 O_CAPTURE_CLKB.n10 O_CAPTURE_CLKB.n9 11.6805
R1366 O_CAPTURE_CLKB.n11 O_CAPTURE_CLKB.n10 11.6805
R1367 O_CAPTURE_CLKB.n12 O_CAPTURE_CLKB.n11 11.6805
R1368 O_CAPTURE_CLKB.n28 O_CAPTURE_CLKB.n27 9.1685
R1369 O_CAPTURE_CLKB.n17 O_CAPTURE_CLKB.n16 7.17687
R1370 O_CAPTURE_CLKB.n5 O_CAPTURE_CLKB.n4 7.17687
R1371 O_CAPTURE_CLKB.n18 O_CAPTURE_CLKB.n17 4.42851
R1372 O_CAPTURE_CLKB.n6 O_CAPTURE_CLKB.n5 4.42851
R1373 O_CAPTURE_CLKB.n27 O_CAPTURE_CLKB.n14 0.1205
R1374 O_CAPTURE_CLKB.n23 O_CAPTURE_CLKB.n14 0.1205
R1375 O_CAPTURE_CLKB.n23 O_CAPTURE_CLKB.n22 0.1205
R1376 O_CAPTURE_CLKB.n22 O_CAPTURE_CLKB.n21 0.1205
R1377 O_CAPTURE_CLKB.n21 O_CAPTURE_CLKB.n16 0.1205
R1378 O_CAPTURE_CLKB.n13 O_CAPTURE_CLKB.n0 0.1205
R1379 O_CAPTURE_CLKB.n1 O_CAPTURE_CLKB.n0 0.1205
R1380 O_CAPTURE_CLKB.n2 O_CAPTURE_CLKB.n1 0.1205
R1381 O_CAPTURE_CLKB.n3 O_CAPTURE_CLKB.n2 0.1205
R1382 O_CAPTURE_CLKB.n4 O_CAPTURE_CLKB.n3 0.1205
R1383 E_CAPTURE_CLKB.n17 E_CAPTURE_CLKB.t0 113.632
R1384 E_CAPTURE_CLKB.n5 E_CAPTURE_CLKB.t8 113.632
R1385 E_CAPTURE_CLKB.n26 E_CAPTURE_CLKB.t7 109.174
R1386 E_CAPTURE_CLKB.n25 E_CAPTURE_CLKB.t6 109.174
R1387 E_CAPTURE_CLKB.n24 E_CAPTURE_CLKB.t5 109.174
R1388 E_CAPTURE_CLKB.n15 E_CAPTURE_CLKB.t4 109.174
R1389 E_CAPTURE_CLKB.n20 E_CAPTURE_CLKB.t3 109.174
R1390 E_CAPTURE_CLKB.n19 E_CAPTURE_CLKB.t2 109.174
R1391 E_CAPTURE_CLKB.n18 E_CAPTURE_CLKB.t1 109.174
R1392 E_CAPTURE_CLKB.n6 E_CAPTURE_CLKB.t9 109.174
R1393 E_CAPTURE_CLKB.n7 E_CAPTURE_CLKB.t10 109.174
R1394 E_CAPTURE_CLKB.n8 E_CAPTURE_CLKB.t11 109.174
R1395 E_CAPTURE_CLKB.n9 E_CAPTURE_CLKB.t12 109.174
R1396 E_CAPTURE_CLKB.n10 E_CAPTURE_CLKB.t13 109.174
R1397 E_CAPTURE_CLKB.n11 E_CAPTURE_CLKB.t14 109.174
R1398 E_CAPTURE_CLKB.n12 E_CAPTURE_CLKB.t15 109.174
R1399 E_CAPTURE_CLKB E_CAPTURE_CLKB.n28 29.0413
R1400 E_CAPTURE_CLKB.n27 E_CAPTURE_CLKB.n26 18.4942
R1401 E_CAPTURE_CLKB.n25 E_CAPTURE_CLKB.n14 18.4942
R1402 E_CAPTURE_CLKB.n24 E_CAPTURE_CLKB.n23 18.4942
R1403 E_CAPTURE_CLKB.n22 E_CAPTURE_CLKB.n15 18.4942
R1404 E_CAPTURE_CLKB.n21 E_CAPTURE_CLKB.n20 18.4942
R1405 E_CAPTURE_CLKB.n19 E_CAPTURE_CLKB.n16 18.4942
R1406 E_CAPTURE_CLKB.n7 E_CAPTURE_CLKB.n4 18.4942
R1407 E_CAPTURE_CLKB.n8 E_CAPTURE_CLKB.n3 18.4942
R1408 E_CAPTURE_CLKB.n9 E_CAPTURE_CLKB.n2 18.4942
R1409 E_CAPTURE_CLKB.n10 E_CAPTURE_CLKB.n1 18.4942
R1410 E_CAPTURE_CLKB.n11 E_CAPTURE_CLKB.n0 18.4942
R1411 E_CAPTURE_CLKB.n13 E_CAPTURE_CLKB.n12 18.4942
R1412 E_CAPTURE_CLKB.n28 E_CAPTURE_CLKB.n13 14.2555
R1413 E_CAPTURE_CLKB.n26 E_CAPTURE_CLKB.n25 11.6805
R1414 E_CAPTURE_CLKB.n25 E_CAPTURE_CLKB.n24 11.6805
R1415 E_CAPTURE_CLKB.n24 E_CAPTURE_CLKB.n15 11.6805
R1416 E_CAPTURE_CLKB.n20 E_CAPTURE_CLKB.n15 11.6805
R1417 E_CAPTURE_CLKB.n20 E_CAPTURE_CLKB.n19 11.6805
R1418 E_CAPTURE_CLKB.n19 E_CAPTURE_CLKB.n18 11.6805
R1419 E_CAPTURE_CLKB.n7 E_CAPTURE_CLKB.n6 11.6805
R1420 E_CAPTURE_CLKB.n8 E_CAPTURE_CLKB.n7 11.6805
R1421 E_CAPTURE_CLKB.n9 E_CAPTURE_CLKB.n8 11.6805
R1422 E_CAPTURE_CLKB.n10 E_CAPTURE_CLKB.n9 11.6805
R1423 E_CAPTURE_CLKB.n11 E_CAPTURE_CLKB.n10 11.6805
R1424 E_CAPTURE_CLKB.n12 E_CAPTURE_CLKB.n11 11.6805
R1425 E_CAPTURE_CLKB.n28 E_CAPTURE_CLKB.n27 9.1685
R1426 E_CAPTURE_CLKB.n17 E_CAPTURE_CLKB.n16 7.17687
R1427 E_CAPTURE_CLKB.n5 E_CAPTURE_CLKB.n4 7.17687
R1428 E_CAPTURE_CLKB.n18 E_CAPTURE_CLKB.n17 4.42851
R1429 E_CAPTURE_CLKB.n6 E_CAPTURE_CLKB.n5 4.42851
R1430 E_CAPTURE_CLKB.n27 E_CAPTURE_CLKB.n14 0.1205
R1431 E_CAPTURE_CLKB.n23 E_CAPTURE_CLKB.n14 0.1205
R1432 E_CAPTURE_CLKB.n23 E_CAPTURE_CLKB.n22 0.1205
R1433 E_CAPTURE_CLKB.n22 E_CAPTURE_CLKB.n21 0.1205
R1434 E_CAPTURE_CLKB.n21 E_CAPTURE_CLKB.n16 0.1205
R1435 E_CAPTURE_CLKB.n13 E_CAPTURE_CLKB.n0 0.1205
R1436 E_CAPTURE_CLKB.n1 E_CAPTURE_CLKB.n0 0.1205
R1437 E_CAPTURE_CLKB.n2 E_CAPTURE_CLKB.n1 0.1205
R1438 E_CAPTURE_CLKB.n3 E_CAPTURE_CLKB.n2 0.1205
R1439 E_CAPTURE_CLKB.n4 E_CAPTURE_CLKB.n3 0.1205
R1440 VDD.t426 VDD.t425 2823.53
R1441 VDD.t428 VDD.t427 2823.53
R1442 VDD.t427 VDD.t426 1411.76
R1443 VDD.n5 VDD.t345 923.077
R1444 VDD.n6 VDD.t500 923.077
R1445 VDD.n10 VDD.t504 923.077
R1446 VDD.n11 VDD.t212 923.077
R1447 VDD.n15 VDD.t461 923.077
R1448 VDD.n16 VDD.t290 923.077
R1449 VDD.t503 VDD.t347 640.625
R1450 VDD.t507 VDD.t502 640.625
R1451 VDD.t215 VDD.t506 640.625
R1452 VDD.t464 VDD.t214 640.625
R1453 VDD.t293 VDD.t463 640.625
R1454 VDD.t219 VDD.t292 640.625
R1455 VDD.n3 VDD.t345 483.238
R1456 VDD.t500 VDD.n5 461.538
R1457 VDD.n6 VDD.t504 461.538
R1458 VDD.t212 VDD.n10 461.538
R1459 VDD.n11 VDD.t461 461.538
R1460 VDD.t290 VDD.n15 461.538
R1461 VDD.n16 VDD.t216 461.538
R1462 VDD.n31 VDD.t428 407.682
R1463 VDD.n19 VDD.t218 313.94
R1464 VDD.n341 VDD.n340 166.667
R1465 VDD.n341 VDD.n326 166.667
R1466 VDD.n358 VDD.n299 166.667
R1467 VDD.n364 VDD.n299 166.667
R1468 VDD.n103 VDD.n102 166.667
R1469 VDD.n103 VDD.n46 166.667
R1470 VDD.n76 VDD.n75 166.667
R1471 VDD.n75 VDD.n59 166.667
R1472 VDD.n263 VDD.n260 166.667
R1473 VDD.n260 VDD.n259 166.667
R1474 VDD.n340 VDD.t395 143.333
R1475 VDD.t393 VDD.n364 143.333
R1476 VDD.n102 VDD.t373 143.333
R1477 VDD.t351 VDD.n59 143.333
R1478 VDD.t99 VDD.n261 126.668
R1479 VDD.n250 VDD.t23 126.668
R1480 VDD.t508 VDD.n285 113.334
R1481 VDD.n277 VDD.t344 113.334
R1482 VDD.t141 VDD.n244 113.334
R1483 VDD.n236 VDD.t12 113.334
R1484 VDD.n334 VDD.n333 106.3
R1485 VDD.n297 VDD.n295 106.3
R1486 VDD.n113 VDD.n112 106.3
R1487 VDD.n66 VDD.n65 106.3
R1488 VDD.n288 VDD.n287 106.3
R1489 VDD.n233 VDD.n232 106.3
R1490 VDD.n327 VDD.t222 93.3338
R1491 VDD.n357 VDD.t260 93.3338
R1492 VDD.n99 VDD.t168 93.3338
R1493 VDD.n77 VDD.t210 93.3338
R1494 VDD.n339 VDD.t278 86.6672
R1495 VDD.t389 VDD.n365 86.6672
R1496 VDD.t377 VDD.n111 86.6672
R1497 VDD.n67 VDD.t359 86.6672
R1498 VDD.n334 VDD.n330 70.0005
R1499 VDD.n338 VDD.n330 70.0005
R1500 VDD.n338 VDD.n325 70.0005
R1501 VDD.n342 VDD.n325 70.0005
R1502 VDD.n342 VDD.n319 70.0005
R1503 VDD.n346 VDD.n319 70.0005
R1504 VDD.n346 VDD.n317 70.0005
R1505 VDD.n349 VDD.n317 70.0005
R1506 VDD.n349 VDD.n309 70.0005
R1507 VDD.n353 VDD.n309 70.0005
R1508 VDD.n353 VDD.n308 70.0005
R1509 VDD.n308 VDD.n305 70.0005
R1510 VDD.n359 VDD.n305 70.0005
R1511 VDD.n359 VDD.n300 70.0005
R1512 VDD.n363 VDD.n300 70.0005
R1513 VDD.n363 VDD.n296 70.0005
R1514 VDD.n366 VDD.n296 70.0005
R1515 VDD.n366 VDD.n295 70.0005
R1516 VDD.n113 VDD.n40 70.0005
R1517 VDD.n110 VDD.n40 70.0005
R1518 VDD.n110 VDD.n41 70.0005
R1519 VDD.n104 VDD.n41 70.0005
R1520 VDD.n104 VDD.n45 70.0005
R1521 VDD.n97 VDD.n45 70.0005
R1522 VDD.n97 VDD.n48 70.0005
R1523 VDD.n91 VDD.n48 70.0005
R1524 VDD.n91 VDD.n52 70.0005
R1525 VDD.n88 VDD.n52 70.0005
R1526 VDD.n88 VDD.n53 70.0005
R1527 VDD.n82 VDD.n53 70.0005
R1528 VDD.n82 VDD.n57 70.0005
R1529 VDD.n74 VDD.n57 70.0005
R1530 VDD.n74 VDD.n60 70.0005
R1531 VDD.n68 VDD.n60 70.0005
R1532 VDD.n68 VDD.n64 70.0005
R1533 VDD.n65 VDD.n64 70.0005
R1534 VDD.n288 VDD.n209 70.0005
R1535 VDD.n284 VDD.n209 70.0005
R1536 VDD.n284 VDD.n210 70.0005
R1537 VDD.n278 VDD.n210 70.0005
R1538 VDD.n278 VDD.n214 70.0005
R1539 VDD.n270 VDD.n214 70.0005
R1540 VDD.n270 VDD.n216 70.0005
R1541 VDD.n264 VDD.n216 70.0005
R1542 VDD.n264 VDD.n220 70.0005
R1543 VDD.n258 VDD.n220 70.0005
R1544 VDD.n258 VDD.n221 70.0005
R1545 VDD.n252 VDD.n221 70.0005
R1546 VDD.n252 VDD.n225 70.0005
R1547 VDD.n243 VDD.n225 70.0005
R1548 VDD.n243 VDD.n227 70.0005
R1549 VDD.n237 VDD.n227 70.0005
R1550 VDD.n237 VDD.n231 70.0005
R1551 VDD.n232 VDD.n231 70.0005
R1552 VDD.n327 VDD.n326 66.6672
R1553 VDD.n358 VDD.n357 66.6672
R1554 VDD.n99 VDD.n46 66.6672
R1555 VDD.n77 VDD.n76 66.6672
R1556 VDD.n287 VDD.n286 66.6672
R1557 VDD.n273 VDD.n272 66.6672
R1558 VDD.n246 VDD.n245 66.6672
R1559 VDD.n234 VDD.n233 66.6672
R1560 VDD.t347 VDD.t348 62.5005
R1561 VDD.t502 VDD.t503 62.5005
R1562 VDD.t506 VDD.t507 62.5005
R1563 VDD.t214 VDD.t215 62.5005
R1564 VDD.t463 VDD.t464 62.5005
R1565 VDD.t292 VDD.t293 62.5005
R1566 VDD.t218 VDD.t219 62.5005
R1567 VDD.n333 VDD.t152 53.3338
R1568 VDD.t235 VDD.t162 53.3338
R1569 VDD.t162 VDD.t237 53.3338
R1570 VDD.t242 VDD.t160 53.3338
R1571 VDD.t160 VDD.t243 53.3338
R1572 VDD.t282 VDD.n297 53.3338
R1573 VDD.n112 VDD.t154 53.3338
R1574 VDD.t182 VDD.t158 53.3338
R1575 VDD.t158 VDD.t184 53.3338
R1576 VDD.t191 VDD.t156 53.3338
R1577 VDD.t156 VDD.t192 53.3338
R1578 VDD.t361 VDD.n66 53.3338
R1579 VDD.n276 VDD.t336 53.3338
R1580 VDD.t25 VDD.n276 53.3338
R1581 VDD.n273 VDD.t304 53.3338
R1582 VDD.n246 VDD.t512 53.3338
R1583 VDD.n235 VDD.t127 53.3338
R1584 VDD.t466 VDD.n235 53.3338
R1585 VDD.n261 VDD.t568 46.6672
R1586 VDD.t276 VDD.n250 46.6672
R1587 VDD.t18 VDD.t315 33.3338
R1588 VDD.t514 VDD.t8 33.3338
R1589 VDD.n263 VDD.t131 26.6672
R1590 VDD.n259 VDD.t553 26.6672
R1591 VDD.n508 VDD.n507 25.203
R1592 VDD.n544 VDD.n543 25.203
R1593 VDD.n24 VDD.t93 25.1121
R1594 VDD.n26 VDD.t0 24.7565
R1595 VDD.n30 VDD.t94 24.7565
R1596 VDD.n27 VDD.t1 24.7565
R1597 VDD.n449 VDD.n448 24.4328
R1598 VDD.n395 VDD.n394 24.4328
R1599 VDD.n128 VDD.n127 24.4328
R1600 VDD.n195 VDD.n194 24.4328
R1601 VDD.n371 VDD.n370 22.1797
R1602 VDD.n386 VDD.n385 22.1797
R1603 VDD.n130 VDD.n129 22.1797
R1604 VDD.n117 VDD.n116 22.1797
R1605 VDD.n531 VDD.n530 22.1735
R1606 VDD.n21 VDD.t112 22.1461
R1607 VDD.n32 VDD.t552 21.9006
R1608 VDD.n33 VDD.t139 21.9006
R1609 VDD.n17 VDD.n16 21.6005
R1610 VDD.n15 VDD.n14 21.6005
R1611 VDD.n12 VDD.n11 21.6005
R1612 VDD.n10 VDD.n9 21.6005
R1613 VDD.n7 VDD.n6 21.6005
R1614 VDD.n5 VDD.n4 21.6005
R1615 VDD.n32 VDD.t555 21.545
R1616 VDD.n33 VDD.t88 21.545
R1617 VDD.n29 VDD.t107 21.4505
R1618 VDD.n28 VDD.t140 21.4505
R1619 VDD.n21 VDD.t105 21.435
R1620 VDD.n23 VDD.t106 21.435
R1621 VDD.n22 VDD.t20 21.435
R1622 VDD.n25 VDD.t264 21.3935
R1623 VDD.n24 VDD.t265 21.3935
R1624 VDD.n285 VDD.t324 20.0005
R1625 VDD.n277 VDD.t39 20.0005
R1626 VDD.n244 VDD.t113 20.0005
R1627 VDD.n236 VDD.t478 20.0005
R1628 VDD.n493 VDD.n486 19.5039
R1629 VDD.n562 VDD.n555 19.5039
R1630 VDD.n398 VDD.n396 19.4916
R1631 VDD.n193 VDD.n192 19.4916
R1632 VDD.n447 VDD.n446 19.4916
R1633 VDD.n133 VDD.n131 19.4916
R1634 VDD.n499 VDD.n497 19.4092
R1635 VDD.n506 VDD.n505 19.4092
R1636 VDD.n547 VDD.n545 19.4092
R1637 VDD.n554 VDD.n553 19.4092
R1638 VDD.n458 VDD.n457 19.0179
R1639 VDD.n456 VDD.n450 19.0179
R1640 VDD.n198 VDD.n196 19.0179
R1641 VDD.n204 VDD.n203 19.0179
R1642 VDD.n290 VDD.n289 18.3116
R1643 VDD.n369 VDD.n292 18.1338
R1644 VDD.n115 VDD.n114 18.1338
R1645 VDD.n337 VDD.n332 18.0005
R1646 VDD.n331 VDD.n324 18.0005
R1647 VDD.n343 VDD.n323 18.0005
R1648 VDD.n344 VDD.n322 18.0005
R1649 VDD.n345 VDD.n321 18.0005
R1650 VDD.n320 VDD.n316 18.0005
R1651 VDD.n350 VDD.n315 18.0005
R1652 VDD.n351 VDD.n314 18.0005
R1653 VDD.n352 VDD.n313 18.0005
R1654 VDD.n312 VDD.n310 18.0005
R1655 VDD.n311 VDD.n304 18.0005
R1656 VDD.n360 VDD.n303 18.0005
R1657 VDD.n361 VDD.n302 18.0005
R1658 VDD.n362 VDD.n301 18.0005
R1659 VDD.n294 VDD.n293 18.0005
R1660 VDD.n368 VDD.n367 18.0005
R1661 VDD.n39 VDD.n38 18.0005
R1662 VDD.n109 VDD.n108 18.0005
R1663 VDD.n107 VDD.n42 18.0005
R1664 VDD.n106 VDD.n105 18.0005
R1665 VDD.n44 VDD.n43 18.0005
R1666 VDD.n96 VDD.n95 18.0005
R1667 VDD.n94 VDD.n49 18.0005
R1668 VDD.n93 VDD.n92 18.0005
R1669 VDD.n51 VDD.n50 18.0005
R1670 VDD.n87 VDD.n86 18.0005
R1671 VDD.n85 VDD.n54 18.0005
R1672 VDD.n84 VDD.n83 18.0005
R1673 VDD.n56 VDD.n55 18.0005
R1674 VDD.n73 VDD.n72 18.0005
R1675 VDD.n71 VDD.n61 18.0005
R1676 VDD.n70 VDD.n69 18.0005
R1677 VDD.n208 VDD.n207 18.0005
R1678 VDD.n283 VDD.n282 18.0005
R1679 VDD.n281 VDD.n211 18.0005
R1680 VDD.n280 VDD.n279 18.0005
R1681 VDD.n213 VDD.n212 18.0005
R1682 VDD.n269 VDD.n268 18.0005
R1683 VDD.n267 VDD.n217 18.0005
R1684 VDD.n266 VDD.n265 18.0005
R1685 VDD.n219 VDD.n218 18.0005
R1686 VDD.n257 VDD.n256 18.0005
R1687 VDD.n255 VDD.n222 18.0005
R1688 VDD.n254 VDD.n253 18.0005
R1689 VDD.n224 VDD.n223 18.0005
R1690 VDD.n242 VDD.n241 18.0005
R1691 VDD.n240 VDD.n228 18.0005
R1692 VDD.n239 VDD.n238 18.0005
R1693 VDD.n333 VDD.n329 17.6849
R1694 VDD.n66 VDD.n58 17.6847
R1695 VDD.n233 VDD.n226 17.6847
R1696 VDD.n517 VDD.n509 16.9481
R1697 VDD.n287 VDD.n206 16.4744
R1698 VDD.n340 VDD.n329 16.4218
R1699 VDD.n328 VDD.n327 16.4218
R1700 VDD.n348 VDD.n306 16.4218
R1701 VDD.n355 VDD.n354 16.4218
R1702 VDD.n357 VDD.n356 16.4218
R1703 VDD.n364 VDD.n298 16.4218
R1704 VDD.n112 VDD.n37 16.4218
R1705 VDD.n102 VDD.n101 16.4218
R1706 VDD.n100 VDD.n99 16.4218
R1707 VDD.n90 VDD.n47 16.4218
R1708 VDD.n80 VDD.n79 16.4218
R1709 VDD.n78 VDD.n77 16.4218
R1710 VDD.n59 VDD.n58 16.4218
R1711 VDD.n276 VDD.n275 16.4218
R1712 VDD.n274 VDD.n273 16.4218
R1713 VDD.n262 VDD.n215 16.4218
R1714 VDD.n249 VDD.n248 16.4218
R1715 VDD.n247 VDD.n246 16.4218
R1716 VDD.n235 VDD.n226 16.4218
R1717 VDD.n297 VDD.n291 16.4215
R1718 VDD.n430 VDD.n421 14.8005
R1719 VDD.n417 VDD.n408 14.8005
R1720 VDD.n160 VDD.n151 14.8005
R1721 VDD.n173 VDD.n164 14.8005
R1722 VDD.n486 VDD.n485 14.6703
R1723 VDD.n411 VDD.n407 14.6065
R1724 VDD.n153 VDD.n150 14.6065
R1725 VDD.n481 VDD.n477 13.7564
R1726 VDD.n569 VDD.n568 13.4387
R1727 VDD.t152 VDD.t150 13.3338
R1728 VDD.t150 VDD.t405 13.3338
R1729 VDD.t405 VDD.t403 13.3338
R1730 VDD.t403 VDD.t401 13.3338
R1731 VDD.t401 VDD.t399 13.3338
R1732 VDD.t399 VDD.t280 13.3338
R1733 VDD.t280 VDD.t278 13.3338
R1734 VDD.t395 VDD.t397 13.3338
R1735 VDD.t544 VDD.t536 13.3338
R1736 VDD.t542 VDD.t544 13.3338
R1737 VDD.t60 VDD.t58 13.3338
R1738 VDD.t62 VDD.t60 13.3338
R1739 VDD.t48 VDD.t62 13.3338
R1740 VDD.t375 VDD.t376 13.3338
R1741 VDD.t370 VDD.t375 13.3338
R1742 VDD.t369 VDD.t370 13.3338
R1743 VDD.t372 VDD.t369 13.3338
R1744 VDD.t371 VDD.t372 13.3338
R1745 VDD.t559 VDD.t371 13.3338
R1746 VDD.t558 VDD.t559 13.3338
R1747 VDD.t229 VDD.t220 13.3338
R1748 VDD.t231 VDD.t229 13.3338
R1749 VDD.t78 VDD.t231 13.3338
R1750 VDD.t227 VDD.t82 13.3338
R1751 VDD.t224 VDD.t227 13.3338
R1752 VDD.t224 VDD.t235 13.3338
R1753 VDD.t237 VDD.t238 13.3338
R1754 VDD.t238 VDD.t239 13.3338
R1755 VDD.t239 VDD.t84 13.3338
R1756 VDD.t85 VDD.t240 13.3338
R1757 VDD.t240 VDD.t241 13.3338
R1758 VDD.t241 VDD.t242 13.3338
R1759 VDD.t245 VDD.t243 13.3338
R1760 VDD.t247 VDD.t245 13.3338
R1761 VDD.t86 VDD.t247 13.3338
R1762 VDD.t249 VDD.t80 13.3338
R1763 VDD.t252 VDD.t249 13.3338
R1764 VDD.t254 VDD.t252 13.3338
R1765 VDD.t532 VDD.t533 13.3338
R1766 VDD.t571 VDD.t532 13.3338
R1767 VDD.t570 VDD.t571 13.3338
R1768 VDD.t535 VDD.t570 13.3338
R1769 VDD.t534 VDD.t535 13.3338
R1770 VDD.t541 VDD.t534 13.3338
R1771 VDD.t541 VDD.t540 13.3338
R1772 VDD.t64 VDD.t66 13.3338
R1773 VDD.t66 VDD.t46 13.3338
R1774 VDD.t46 VDD.t72 13.3338
R1775 VDD.t560 VDD.t274 13.3338
R1776 VDD.t274 VDD.t272 13.3338
R1777 VDD.t391 VDD.t393 13.3338
R1778 VDD.t387 VDD.t389 13.3338
R1779 VDD.t385 VDD.t387 13.3338
R1780 VDD.t383 VDD.t385 13.3338
R1781 VDD.t288 VDD.t383 13.3338
R1782 VDD.t286 VDD.t288 13.3338
R1783 VDD.t284 VDD.t286 13.3338
R1784 VDD.t284 VDD.t282 13.3338
R1785 VDD.t154 VDD.t148 13.3338
R1786 VDD.t148 VDD.t146 13.3338
R1787 VDD.t146 VDD.t144 13.3338
R1788 VDD.t144 VDD.t142 13.3338
R1789 VDD.t142 VDD.t381 13.3338
R1790 VDD.t381 VDD.t379 13.3338
R1791 VDD.t379 VDD.t377 13.3338
R1792 VDD.t373 VDD.t342 13.3338
R1793 VDD.t91 VDD.t108 13.3338
R1794 VDD.t89 VDD.t91 13.3338
R1795 VDD.t441 VDD.t439 13.3338
R1796 VDD.t443 VDD.t441 13.3338
R1797 VDD.t445 VDD.t443 13.3338
R1798 VDD.t410 VDD.t407 13.3338
R1799 VDD.t409 VDD.t410 13.3338
R1800 VDD.t408 VDD.t409 13.3338
R1801 VDD.t413 VDD.t408 13.3338
R1802 VDD.t412 VDD.t413 13.3338
R1803 VDD.t411 VDD.t412 13.3338
R1804 VDD.t418 VDD.t411 13.3338
R1805 VDD.t174 VDD.t172 13.3338
R1806 VDD.t166 VDD.t174 13.3338
R1807 VDD.t164 VDD.t166 13.3338
R1808 VDD.t178 VDD.t176 13.3338
R1809 VDD.t180 VDD.t178 13.3338
R1810 VDD.t180 VDD.t182 13.3338
R1811 VDD.t184 VDD.t185 13.3338
R1812 VDD.t185 VDD.t186 13.3338
R1813 VDD.t186 VDD.t187 13.3338
R1814 VDD.t188 VDD.t189 13.3338
R1815 VDD.t189 VDD.t190 13.3338
R1816 VDD.t190 VDD.t191 13.3338
R1817 VDD.t192 VDD.t194 13.3338
R1818 VDD.t194 VDD.t170 13.3338
R1819 VDD.t198 VDD.t170 13.3338
R1820 VDD.t196 VDD.t200 13.3338
R1821 VDD.t202 VDD.t196 13.3338
R1822 VDD.t204 VDD.t202 13.3338
R1823 VDD.t546 VDD.t547 13.3338
R1824 VDD.t134 VDD.t546 13.3338
R1825 VDD.t133 VDD.t134 13.3338
R1826 VDD.t487 VDD.t133 13.3338
R1827 VDD.t486 VDD.t487 13.3338
R1828 VDD.t104 VDD.t486 13.3338
R1829 VDD.t103 VDD.t104 13.3338
R1830 VDD.t437 VDD.t447 13.3338
R1831 VDD.t449 VDD.t437 13.3338
R1832 VDD.t451 VDD.t449 13.3338
R1833 VDD.t423 VDD.t480 13.3338
R1834 VDD.t421 VDD.t423 13.3338
R1835 VDD.t349 VDD.t351 13.3338
R1836 VDD.t359 VDD.t357 13.3338
R1837 VDD.t357 VDD.t355 13.3338
R1838 VDD.t355 VDD.t353 13.3338
R1839 VDD.t353 VDD.t367 13.3338
R1840 VDD.t367 VDD.t365 13.3338
R1841 VDD.t365 VDD.t363 13.3338
R1842 VDD.t363 VDD.t361 13.3338
R1843 VDD.n286 VDD.t566 13.3338
R1844 VDD.t566 VDD.t101 13.3338
R1845 VDD.t101 VDD.t4 13.3338
R1846 VDD.t4 VDD.t508 13.3338
R1847 VDD.t322 VDD.t324 13.3338
R1848 VDD.t326 VDD.t322 13.3338
R1849 VDD.t328 VDD.t326 13.3338
R1850 VDD.t332 VDD.t328 13.3338
R1851 VDD.t334 VDD.t332 13.3338
R1852 VDD.t330 VDD.t334 13.3338
R1853 VDD.t336 VDD.t330 13.3338
R1854 VDD.t29 VDD.t25 13.3338
R1855 VDD.t31 VDD.t29 13.3338
R1856 VDD.t27 VDD.t31 13.3338
R1857 VDD.t33 VDD.t27 13.3338
R1858 VDD.t35 VDD.t33 13.3338
R1859 VDD.t37 VDD.t35 13.3338
R1860 VDD.t39 VDD.t37 13.3338
R1861 VDD.t129 VDD.t344 13.3338
R1862 VDD.t7 VDD.t129 13.3338
R1863 VDD.t6 VDD.t7 13.3338
R1864 VDD.n272 VDD.t6 13.3338
R1865 VDD.t304 VDD.t298 13.3338
R1866 VDD.t298 VDD.t307 13.3338
R1867 VDD.t307 VDD.t302 13.3338
R1868 VDD.t313 VDD.t300 13.3338
R1869 VDD.t309 VDD.t313 13.3338
R1870 VDD.t315 VDD.t309 13.3338
R1871 VDD.t42 VDD.t18 13.3338
R1872 VDD.t44 VDD.t42 13.3338
R1873 VDD.t568 VDD.t44 13.3338
R1874 VDD.t556 VDD.t276 13.3338
R1875 VDD.t262 VDD.t556 13.3338
R1876 VDD.t8 VDD.t262 13.3338
R1877 VDD.t517 VDD.t514 13.3338
R1878 VDD.t519 VDD.t517 13.3338
R1879 VDD.t16 VDD.t519 13.3338
R1880 VDD.t510 VDD.t14 13.3338
R1881 VDD.t523 VDD.t510 13.3338
R1882 VDD.t512 VDD.t523 13.3338
R1883 VDD.n245 VDD.t41 13.3338
R1884 VDD.t41 VDD.t21 13.3338
R1885 VDD.t21 VDD.t2 13.3338
R1886 VDD.t2 VDD.t141 13.3338
R1887 VDD.t117 VDD.t113 13.3338
R1888 VDD.t115 VDD.t117 13.3338
R1889 VDD.t119 VDD.t115 13.3338
R1890 VDD.t123 VDD.t119 13.3338
R1891 VDD.t125 VDD.t123 13.3338
R1892 VDD.t121 VDD.t125 13.3338
R1893 VDD.t127 VDD.t121 13.3338
R1894 VDD.t468 VDD.t466 13.3338
R1895 VDD.t470 VDD.t468 13.3338
R1896 VDD.t97 VDD.t470 13.3338
R1897 VDD.t95 VDD.t97 13.3338
R1898 VDD.t474 VDD.t95 13.3338
R1899 VDD.t472 VDD.t474 13.3338
R1900 VDD.t478 VDD.t472 13.3338
R1901 VDD.t12 VDD.t340 13.3338
R1902 VDD.t340 VDD.t338 13.3338
R1903 VDD.t338 VDD.t10 13.3338
R1904 VDD.t10 VDD.n234 13.3338
R1905 VDD.n518 VDD.n482 13.2291
R1906 VDD.n475 VDD.n462 13.2291
R1907 VDD.n540 VDD.n532 12.3348
R1908 VDD.n434 VDD.n432 12.2524
R1909 VDD.n177 VDD.n175 12.2524
R1910 VDD.n496 VDD.n495 11.9744
R1911 VDD.n565 VDD.n564 11.9744
R1912 VDD.n440 VDD.n438 11.8107
R1913 VDD.n186 VDD.n184 11.8107
R1914 VDD.n406 VDD.n405 11.7788
R1915 VDD.n149 VDD.n148 11.7788
R1916 VDD.n402 VDD.n401 11.7396
R1917 VDD.n140 VDD.n139 11.7396
R1918 VDD.n3 VDD.t346 11.724
R1919 VDD.n2 VDD.t501 11.724
R1920 VDD.n8 VDD.t505 11.724
R1921 VDD.n1 VDD.t213 11.724
R1922 VDD.n13 VDD.t462 11.724
R1923 VDD.n0 VDD.t291 11.724
R1924 VDD.n18 VDD.t217 11.724
R1925 VDD.n395 VDD.n393 10.5755
R1926 VDD.n128 VDD.n126 10.5755
R1927 VDD.n428 VDD.t161 10.4271
R1928 VDD.n418 VDD.t163 10.4271
R1929 VDD.n161 VDD.t157 10.4271
R1930 VDD.n165 VDD.t159 10.4271
R1931 VDD.n19 VDD.n18 10.4005
R1932 VDD.n495 VDD.n494 10.1049
R1933 VDD.n564 VDD.n563 10.1049
R1934 VDD.t397 VDD.n339 10.0005
R1935 VDD.t536 VDD.t256 10.0005
R1936 VDD.t52 VDD.t542 10.0005
R1937 VDD.t56 VDD.t490 10.0005
R1938 VDD.t54 VDD.t488 10.0005
R1939 VDD.t50 VDD.t494 10.0005
R1940 VDD.t58 VDD.t492 10.0005
R1941 VDD.t72 VDD.t268 10.0005
R1942 VDD.t70 VDD.t266 10.0005
R1943 VDD.t68 VDD.t564 10.0005
R1944 VDD.t74 VDD.t562 10.0005
R1945 VDD.t76 VDD.t560 10.0005
R1946 VDD.t272 VDD.t258 10.0005
R1947 VDD.n365 VDD.t391 10.0005
R1948 VDD.n111 VDD.t342 10.0005
R1949 VDD.t108 VDD.t206 10.0005
R1950 VDD.t431 VDD.t89 10.0005
R1951 VDD.t429 VDD.t550 10.0005
R1952 VDD.t433 VDD.t548 10.0005
R1953 VDD.t435 VDD.t137 10.0005
R1954 VDD.t439 VDD.t135 10.0005
R1955 VDD.t416 VDD.t451 10.0005
R1956 VDD.t414 VDD.t453 10.0005
R1957 VDD.t484 VDD.t455 10.0005
R1958 VDD.t482 VDD.t457 10.0005
R1959 VDD.t480 VDD.t459 10.0005
R1960 VDD.t208 VDD.t421 10.0005
R1961 VDD.n67 VDD.t349 10.0005
R1962 VDD.n431 VDD.n430 9.82224
R1963 VDD.n174 VDD.n173 9.82224
R1964 VDD.n335 VDD.n332 9.31191
R1965 VDD.n70 VDD.n62 9.31191
R1966 VDD.n239 VDD.n229 9.31191
R1967 VDD.n466 VDD.n461 8.84398
R1968 VDD.n573 VDD.n572 8.7105
R1969 VDD.n474 VDD.n466 8.00988
R1970 VDD.n495 VDD.n493 7.43528
R1971 VDD.n564 VDD.n562 7.43528
R1972 VDD.n438 VDD.n372 7.27876
R1973 VDD.n428 VDD.n420 7.27876
R1974 VDD.n419 VDD.n418 7.27876
R1975 VDD.n402 VDD.n376 7.27876
R1976 VDD.n140 VDD.n119 7.27876
R1977 VDD.n162 VDD.n161 7.27876
R1978 VDD.n165 VDD.n163 7.27876
R1979 VDD.n184 VDD.n118 7.27876
R1980 VDD.n429 VDD.n428 7.13872
R1981 VDD.n172 VDD.n165 7.13872
R1982 VDD.n519 VDD.n476 6.88746
R1983 VDD.n529 VDD.n528 6.88746
R1984 VDD.n542 VDD.n541 6.88746
R1985 VDD.n335 VDD.n334 6.79358
R1986 VDD.n65 VDD.n62 6.79358
R1987 VDD.n232 VDD.n229 6.79358
R1988 VDD.n347 VDD.t222 6.66717
R1989 VDD.t376 VDD.t48 6.66717
R1990 VDD.t220 VDD.t558 6.66717
R1991 VDD.n348 VDD.t78 6.66717
R1992 VDD.t82 VDD.n348 6.66717
R1993 VDD.t84 VDD.n318 6.66717
R1994 VDD.n318 VDD.t85 6.66717
R1995 VDD.n354 VDD.t86 6.66717
R1996 VDD.n354 VDD.t80 6.66717
R1997 VDD.t533 VDD.t254 6.66717
R1998 VDD.t540 VDD.t64 6.66717
R1999 VDD.n307 VDD.t260 6.66717
R2000 VDD.t168 VDD.n98 6.66717
R2001 VDD.t407 VDD.t445 6.66717
R2002 VDD.t172 VDD.t418 6.66717
R2003 VDD.n90 VDD.t164 6.66717
R2004 VDD.t176 VDD.n90 6.66717
R2005 VDD.t187 VDD.n89 6.66717
R2006 VDD.n89 VDD.t188 6.66717
R2007 VDD.n80 VDD.t198 6.66717
R2008 VDD.t200 VDD.n80 6.66717
R2009 VDD.t547 VDD.t204 6.66717
R2010 VDD.t447 VDD.t103 6.66717
R2011 VDD.n81 VDD.t210 6.66717
R2012 VDD.t302 VDD.n271 6.66717
R2013 VDD.n271 VDD.t300 6.66717
R2014 VDD.n262 VDD.t99 6.66717
R2015 VDD.t131 VDD.n262 6.66717
R2016 VDD.n249 VDD.t553 6.66717
R2017 VDD.t23 VDD.n249 6.66717
R2018 VDD.n251 VDD.t16 6.66717
R2019 VDD.n251 VDD.t14 6.66717
R2020 VDD.n295 VDD.n292 6.3005
R2021 VDD.n366 VDD.t284 6.3005
R2022 VDD.n367 VDD.n366 6.3005
R2023 VDD.n365 VDD.n296 6.3005
R2024 VDD.n296 VDD.n294 6.3005
R2025 VDD.n364 VDD.n363 6.3005
R2026 VDD.n363 VDD.n362 6.3005
R2027 VDD.n300 VDD.n299 6.3005
R2028 VDD.n361 VDD.n300 6.3005
R2029 VDD.n359 VDD.n358 6.3005
R2030 VDD.n360 VDD.n359 6.3005
R2031 VDD.n307 VDD.n305 6.3005
R2032 VDD.n305 VDD.n304 6.3005
R2033 VDD.n308 VDD.t541 6.3005
R2034 VDD.n310 VDD.n308 6.3005
R2035 VDD.t245 VDD.n353 6.3005
R2036 VDD.n353 VDD.n352 6.3005
R2037 VDD.n318 VDD.n309 6.3005
R2038 VDD.n351 VDD.n309 6.3005
R2039 VDD.n349 VDD.t224 6.3005
R2040 VDD.n350 VDD.n349 6.3005
R2041 VDD.t375 VDD.n317 6.3005
R2042 VDD.n317 VDD.n316 6.3005
R2043 VDD.n347 VDD.n346 6.3005
R2044 VDD.n346 VDD.n345 6.3005
R2045 VDD.n326 VDD.n319 6.3005
R2046 VDD.n344 VDD.n319 6.3005
R2047 VDD.n342 VDD.n341 6.3005
R2048 VDD.n343 VDD.n342 6.3005
R2049 VDD.n340 VDD.n325 6.3005
R2050 VDD.n325 VDD.n324 6.3005
R2051 VDD.n339 VDD.n338 6.3005
R2052 VDD.n338 VDD.n337 6.3005
R2053 VDD.t150 VDD.n330 6.3005
R2054 VDD.n336 VDD.n330 6.3005
R2055 VDD.t363 VDD.n64 6.3005
R2056 VDD.n64 VDD.n63 6.3005
R2057 VDD.n68 VDD.n67 6.3005
R2058 VDD.n69 VDD.n68 6.3005
R2059 VDD.n60 VDD.n59 6.3005
R2060 VDD.n61 VDD.n60 6.3005
R2061 VDD.n75 VDD.n74 6.3005
R2062 VDD.n74 VDD.n73 6.3005
R2063 VDD.n76 VDD.n57 6.3005
R2064 VDD.n57 VDD.n56 6.3005
R2065 VDD.n82 VDD.n81 6.3005
R2066 VDD.n83 VDD.n82 6.3005
R2067 VDD.t104 VDD.n53 6.3005
R2068 VDD.n54 VDD.n53 6.3005
R2069 VDD.t194 VDD.n88 6.3005
R2070 VDD.n88 VDD.n87 6.3005
R2071 VDD.n89 VDD.n52 6.3005
R2072 VDD.n52 VDD.n51 6.3005
R2073 VDD.n91 VDD.t180 6.3005
R2074 VDD.n92 VDD.n91 6.3005
R2075 VDD.t410 VDD.n48 6.3005
R2076 VDD.n49 VDD.n48 6.3005
R2077 VDD.n98 VDD.n97 6.3005
R2078 VDD.n97 VDD.n96 6.3005
R2079 VDD.n46 VDD.n45 6.3005
R2080 VDD.n45 VDD.n44 6.3005
R2081 VDD.n104 VDD.n103 6.3005
R2082 VDD.n105 VDD.n104 6.3005
R2083 VDD.n102 VDD.n41 6.3005
R2084 VDD.n42 VDD.n41 6.3005
R2085 VDD.n111 VDD.n110 6.3005
R2086 VDD.n110 VDD.n109 6.3005
R2087 VDD.t148 VDD.n40 6.3005
R2088 VDD.n40 VDD.n39 6.3005
R2089 VDD.n114 VDD.n113 6.3005
R2090 VDD.n289 VDD.n288 6.3005
R2091 VDD.n286 VDD.n209 6.3005
R2092 VDD.n209 VDD.n208 6.3005
R2093 VDD.n285 VDD.n284 6.3005
R2094 VDD.n284 VDD.n283 6.3005
R2095 VDD.n276 VDD.n210 6.3005
R2096 VDD.n211 VDD.n210 6.3005
R2097 VDD.n278 VDD.n277 6.3005
R2098 VDD.n279 VDD.n278 6.3005
R2099 VDD.n272 VDD.n214 6.3005
R2100 VDD.n214 VDD.n213 6.3005
R2101 VDD.n271 VDD.n270 6.3005
R2102 VDD.n270 VDD.n269 6.3005
R2103 VDD.n261 VDD.n216 6.3005
R2104 VDD.n217 VDD.n216 6.3005
R2105 VDD.n264 VDD.n263 6.3005
R2106 VDD.n265 VDD.n264 6.3005
R2107 VDD.n260 VDD.n220 6.3005
R2108 VDD.n220 VDD.n219 6.3005
R2109 VDD.n259 VDD.n258 6.3005
R2110 VDD.n258 VDD.n257 6.3005
R2111 VDD.n250 VDD.n221 6.3005
R2112 VDD.n222 VDD.n221 6.3005
R2113 VDD.n252 VDD.n251 6.3005
R2114 VDD.n253 VDD.n252 6.3005
R2115 VDD.n245 VDD.n225 6.3005
R2116 VDD.n225 VDD.n224 6.3005
R2117 VDD.n244 VDD.n243 6.3005
R2118 VDD.n243 VDD.n242 6.3005
R2119 VDD.n235 VDD.n227 6.3005
R2120 VDD.n228 VDD.n227 6.3005
R2121 VDD.n237 VDD.n236 6.3005
R2122 VDD.n238 VDD.n237 6.3005
R2123 VDD.n234 VDD.n231 6.3005
R2124 VDD.n231 VDD.n230 6.3005
R2125 VDD.n459 VDD.n458 5.66103
R2126 VDD.n205 VDD.n204 5.66103
R2127 VDD.n460 VDD.n20 5.6305
R2128 VDD.n528 VDD.n527 5.54261
R2129 VDD.n453 VDD.n451 5.51014
R2130 VDD.n375 VDD.n373 5.51014
R2131 VDD.n424 VDD.n422 5.51014
R2132 VDD.n384 VDD.n382 5.51014
R2133 VDD.n379 VDD.n377 5.51014
R2134 VDD.n389 VDD.n387 5.51014
R2135 VDD.n123 VDD.n121 5.51014
R2136 VDD.n145 VDD.n143 5.51014
R2137 VDD.n138 VDD.n136 5.51014
R2138 VDD.n168 VDD.n166 5.51014
R2139 VDD.n182 VDD.n180 5.51014
R2140 VDD.n201 VDD.n199 5.51014
R2141 VDD.n485 VDD.n483 5.51014
R2142 VDD.n489 VDD.n487 5.51014
R2143 VDD.n502 VDD.n500 5.51014
R2144 VDD.n480 VDD.n478 5.51014
R2145 VDD.n512 VDD.n510 5.51014
R2146 VDD.n465 VDD.n463 5.51014
R2147 VDD.n469 VDD.n467 5.51014
R2148 VDD.n535 VDD.n533 5.51014
R2149 VDD.n550 VDD.n548 5.51014
R2150 VDD.n558 VDD.n556 5.51014
R2151 VDD.n568 VDD.n566 5.51014
R2152 VDD.n393 VDD.n392 5.4159
R2153 VDD.n126 VDD.n120 5.4159
R2154 VDD.n453 VDD.n452 5.32067
R2155 VDD.n457 VDD.n454 5.32067
R2156 VDD.n456 VDD.n455 5.32067
R2157 VDD.n375 VDD.n374 5.32067
R2158 VDD.n436 VDD.n435 5.32067
R2159 VDD.n434 VDD.n433 5.32067
R2160 VDD.n446 VDD.n445 5.32067
R2161 VDD.n444 VDD.n443 5.32067
R2162 VDD.n442 VDD.n441 5.32067
R2163 VDD.n440 VDD.n439 5.32067
R2164 VDD.n424 VDD.n423 5.32067
R2165 VDD.n426 VDD.n425 5.32067
R2166 VDD.n429 VDD.n427 5.32067
R2167 VDD.n416 VDD.n409 5.32067
R2168 VDD.n415 VDD.n414 5.32067
R2169 VDD.n413 VDD.n412 5.32067
R2170 VDD.n411 VDD.n410 5.32067
R2171 VDD.n384 VDD.n383 5.32067
R2172 VDD.n400 VDD.n399 5.32067
R2173 VDD.n398 VDD.n397 5.32067
R2174 VDD.n379 VDD.n378 5.32067
R2175 VDD.n381 VDD.n380 5.32067
R2176 VDD.n404 VDD.n403 5.32067
R2177 VDD.n389 VDD.n388 5.32067
R2178 VDD.n391 VDD.n390 5.32067
R2179 VDD.n125 VDD.n124 5.32067
R2180 VDD.n123 VDD.n122 5.32067
R2181 VDD.n142 VDD.n141 5.32067
R2182 VDD.n147 VDD.n146 5.32067
R2183 VDD.n145 VDD.n144 5.32067
R2184 VDD.n133 VDD.n132 5.32067
R2185 VDD.n135 VDD.n134 5.32067
R2186 VDD.n138 VDD.n137 5.32067
R2187 VDD.n153 VDD.n152 5.32067
R2188 VDD.n155 VDD.n154 5.32067
R2189 VDD.n157 VDD.n156 5.32067
R2190 VDD.n159 VDD.n158 5.32067
R2191 VDD.n172 VDD.n171 5.32067
R2192 VDD.n170 VDD.n169 5.32067
R2193 VDD.n168 VDD.n167 5.32067
R2194 VDD.n186 VDD.n185 5.32067
R2195 VDD.n188 VDD.n187 5.32067
R2196 VDD.n190 VDD.n189 5.32067
R2197 VDD.n192 VDD.n191 5.32067
R2198 VDD.n177 VDD.n176 5.32067
R2199 VDD.n179 VDD.n178 5.32067
R2200 VDD.n182 VDD.n181 5.32067
R2201 VDD.n198 VDD.n197 5.32067
R2202 VDD.n203 VDD.n202 5.32067
R2203 VDD.n201 VDD.n200 5.32067
R2204 VDD.n485 VDD.n484 5.32067
R2205 VDD.n493 VDD.n492 5.32067
R2206 VDD.n491 VDD.n490 5.32067
R2207 VDD.n489 VDD.n488 5.32067
R2208 VDD.n499 VDD.n498 5.32067
R2209 VDD.n504 VDD.n503 5.32067
R2210 VDD.n502 VDD.n501 5.32067
R2211 VDD.n480 VDD.n479 5.32067
R2212 VDD.n521 VDD.n520 5.32067
R2213 VDD.n523 VDD.n522 5.32067
R2214 VDD.n525 VDD.n524 5.32067
R2215 VDD.n527 VDD.n526 5.32067
R2216 VDD.n516 VDD.n515 5.32067
R2217 VDD.n514 VDD.n513 5.32067
R2218 VDD.n512 VDD.n511 5.32067
R2219 VDD.n465 VDD.n464 5.32067
R2220 VDD.n473 VDD.n472 5.32067
R2221 VDD.n471 VDD.n470 5.32067
R2222 VDD.n469 VDD.n468 5.32067
R2223 VDD.n539 VDD.n538 5.32067
R2224 VDD.n537 VDD.n536 5.32067
R2225 VDD.n535 VDD.n534 5.32067
R2226 VDD.n547 VDD.n546 5.32067
R2227 VDD.n552 VDD.n551 5.32067
R2228 VDD.n550 VDD.n549 5.32067
R2229 VDD.n562 VDD.n561 5.32067
R2230 VDD.n560 VDD.n559 5.32067
R2231 VDD.n558 VDD.n557 5.32067
R2232 VDD.n568 VDD.n567 5.32067
R2233 VDD.n570 VDD.n569 5.28208
R2234 VDD.n519 VDD.n518 5.08746
R2235 VDD.n541 VDD.n475 5.08746
R2236 VDD.n481 VDD.n480 5.02155
R2237 VDD.n521 VDD.n519 4.68997
R2238 VDD.n20 VDD.n19 4.651
R2239 VDD.n404 VDD.n402 4.59524
R2240 VDD.n142 VDD.n140 4.59524
R2241 VDD.n466 VDD.n465 4.54787
R2242 VDD.n438 VDD.n437 4.5005
R2243 VDD.n430 VDD.n429 4.5005
R2244 VDD.n417 VDD.n416 4.5005
R2245 VDD.n160 VDD.n159 4.5005
R2246 VDD.n173 VDD.n172 4.5005
R2247 VDD.n184 VDD.n183 4.5005
R2248 VDD.n518 VDD.n517 4.5005
R2249 VDD.n541 VDD.n540 4.5005
R2250 VDD.n475 VDD.n474 4.5005
R2251 VDD.n571 VDD.n570 4.4605
R2252 VDD.n396 VDD.n395 4.31103
R2253 VDD.n131 VDD.n128 4.31103
R2254 VDD.n449 VDD.n447 4.12155
R2255 VDD.n195 VDD.n193 4.12155
R2256 VDD.t538 VDD.n347 3.33383
R2257 VDD.t256 VDD.t538 3.33383
R2258 VDD.t490 VDD.t52 3.33383
R2259 VDD.t488 VDD.t56 3.33383
R2260 VDD.t494 VDD.t54 3.33383
R2261 VDD.t492 VDD.t50 3.33383
R2262 VDD.t268 VDD.t70 3.33383
R2263 VDD.t266 VDD.t68 3.33383
R2264 VDD.t564 VDD.t74 3.33383
R2265 VDD.t562 VDD.t76 3.33383
R2266 VDD.t258 VDD.t270 3.33383
R2267 VDD.t270 VDD.n307 3.33383
R2268 VDD.n98 VDD.t110 3.33383
R2269 VDD.t206 VDD.t110 3.33383
R2270 VDD.t550 VDD.t431 3.33383
R2271 VDD.t548 VDD.t429 3.33383
R2272 VDD.t137 VDD.t433 3.33383
R2273 VDD.t135 VDD.t435 3.33383
R2274 VDD.t453 VDD.t416 3.33383
R2275 VDD.t455 VDD.t414 3.33383
R2276 VDD.t457 VDD.t484 3.33383
R2277 VDD.t459 VDD.t482 3.33383
R2278 VDD.t419 VDD.t208 3.33383
R2279 VDD.n81 VDD.t419 3.33383
R2280 VDD.n531 VDD.n529 3.26892
R2281 VDD.n35 VDD.n31 3.0962
R2282 VDD.n570 VDD.n460 2.7705
R2283 VDD.n418 VDD.n417 2.54398
R2284 VDD.n161 VDD.n160 2.54398
R2285 VDD.n34 VDD.n32 2.26494
R2286 VDD.n35 VDD.n34 2.20416
R2287 VDD.n420 VDD.n419 2.17945
R2288 VDD.n163 VDD.n162 2.17945
R2289 VDD.n571 VDD.n205 2.1305
R2290 VDD.n460 VDD.n459 2.1005
R2291 VDD.n528 VDD.n481 1.95702
R2292 VDD.n572 VDD.n571 1.8805
R2293 VDD.n529 VDD.n476 1.8005
R2294 VDD.n572 VDD.n36 1.69099
R2295 VDD.n545 VDD.n544 1.61103
R2296 VDD.n569 VDD.n565 1.51629
R2297 VDD.n544 VDD.n542 1.42155
R2298 VDD.n497 VDD.n496 1.42155
R2299 VDD.n329 VDD.n328 1.26366
R2300 VDD.n328 VDD.n306 1.26366
R2301 VDD.n355 VDD.n306 1.26366
R2302 VDD.n356 VDD.n355 1.26366
R2303 VDD.n356 VDD.n298 1.26366
R2304 VDD.n298 VDD.n291 1.26366
R2305 VDD.n101 VDD.n37 1.26366
R2306 VDD.n101 VDD.n100 1.26366
R2307 VDD.n100 VDD.n47 1.26366
R2308 VDD.n79 VDD.n47 1.26366
R2309 VDD.n79 VDD.n78 1.26366
R2310 VDD.n78 VDD.n58 1.26366
R2311 VDD.n275 VDD.n274 1.26366
R2312 VDD.n274 VDD.n215 1.26366
R2313 VDD.n248 VDD.n215 1.26366
R2314 VDD.n248 VDD.n247 1.26366
R2315 VDD.n247 VDD.n226 1.26366
R2316 VDD.n555 VDD.n554 1.23208
R2317 VDD.n275 VDD.n206 1.21103
R2318 VDD.n508 VDD.n506 1.13734
R2319 VDD.n532 VDD.n531 1.08997
R2320 VDD.n407 VDD.n406 1.04261
R2321 VDD.n150 VDD.n149 1.04261
R2322 VDD.n22 VDD.n21 1.03676
R2323 VDD.n337 VDD.n336 1.0005
R2324 VDD.n337 VDD.n324 1.0005
R2325 VDD.n343 VDD.n324 1.0005
R2326 VDD.n344 VDD.n343 1.0005
R2327 VDD.n345 VDD.n344 1.0005
R2328 VDD.n345 VDD.n316 1.0005
R2329 VDD.n350 VDD.n316 1.0005
R2330 VDD.n351 VDD.n350 1.0005
R2331 VDD.n352 VDD.n351 1.0005
R2332 VDD.n352 VDD.n310 1.0005
R2333 VDD.n310 VDD.n304 1.0005
R2334 VDD.n360 VDD.n304 1.0005
R2335 VDD.n361 VDD.n360 1.0005
R2336 VDD.n362 VDD.n361 1.0005
R2337 VDD.n362 VDD.n294 1.0005
R2338 VDD.n367 VDD.n294 1.0005
R2339 VDD.n367 VDD.n292 1.0005
R2340 VDD.n114 VDD.n39 1.0005
R2341 VDD.n109 VDD.n39 1.0005
R2342 VDD.n109 VDD.n42 1.0005
R2343 VDD.n105 VDD.n42 1.0005
R2344 VDD.n105 VDD.n44 1.0005
R2345 VDD.n96 VDD.n44 1.0005
R2346 VDD.n96 VDD.n49 1.0005
R2347 VDD.n92 VDD.n49 1.0005
R2348 VDD.n92 VDD.n51 1.0005
R2349 VDD.n87 VDD.n51 1.0005
R2350 VDD.n87 VDD.n54 1.0005
R2351 VDD.n83 VDD.n54 1.0005
R2352 VDD.n83 VDD.n56 1.0005
R2353 VDD.n73 VDD.n56 1.0005
R2354 VDD.n73 VDD.n61 1.0005
R2355 VDD.n69 VDD.n61 1.0005
R2356 VDD.n69 VDD.n63 1.0005
R2357 VDD.n289 VDD.n208 1.0005
R2358 VDD.n283 VDD.n208 1.0005
R2359 VDD.n283 VDD.n211 1.0005
R2360 VDD.n279 VDD.n211 1.0005
R2361 VDD.n279 VDD.n213 1.0005
R2362 VDD.n269 VDD.n213 1.0005
R2363 VDD.n269 VDD.n217 1.0005
R2364 VDD.n265 VDD.n217 1.0005
R2365 VDD.n265 VDD.n219 1.0005
R2366 VDD.n257 VDD.n219 1.0005
R2367 VDD.n257 VDD.n222 1.0005
R2368 VDD.n253 VDD.n222 1.0005
R2369 VDD.n253 VDD.n224 1.0005
R2370 VDD.n242 VDD.n224 1.0005
R2371 VDD.n242 VDD.n228 1.0005
R2372 VDD.n238 VDD.n228 1.0005
R2373 VDD.n238 VDD.n230 1.0005
R2374 VDD.n432 VDD.n431 0.947868
R2375 VDD.n175 VDD.n174 0.947868
R2376 VDD.n509 VDD.n508 0.947868
R2377 VDD.n36 VDD.n23 0.884153
R2378 VDD.n450 VDD.n449 0.876816
R2379 VDD.n196 VDD.n195 0.876816
R2380 VDD.n419 VDD.n407 0.853132
R2381 VDD.n162 VDD.n150 0.853132
R2382 VDD.n4 VDD.n3 0.8005
R2383 VDD.n7 VDD.n2 0.8005
R2384 VDD.n9 VDD.n8 0.8005
R2385 VDD.n12 VDD.n1 0.8005
R2386 VDD.n14 VDD.n13 0.8005
R2387 VDD.n17 VDD.n0 0.8005
R2388 VDD.n432 VDD.n372 0.758395
R2389 VDD.n175 VDD.n118 0.758395
R2390 VDD.n36 VDD.n35 0.745997
R2391 VDD.n447 VDD.n371 0.592605
R2392 VDD.n193 VDD.n117 0.592605
R2393 VDD.n532 VDD.n461 0.568921
R2394 VDD.n386 VDD.n376 0.521553
R2395 VDD.n372 VDD.n371 0.521553
R2396 VDD.n118 VDD.n117 0.521553
R2397 VDD.n130 VDD.n119 0.521553
R2398 VDD.n336 VDD.n335 0.481712
R2399 VDD.n63 VDD.n62 0.481712
R2400 VDD.n230 VDD.n229 0.481712
R2401 VDD.n509 VDD.n476 0.474184
R2402 VDD.n27 VDD.n26 0.451962
R2403 VDD.n332 VDD.n331 0.444944
R2404 VDD.n331 VDD.n323 0.444944
R2405 VDD.n323 VDD.n322 0.444944
R2406 VDD.n322 VDD.n321 0.444944
R2407 VDD.n321 VDD.n320 0.444944
R2408 VDD.n320 VDD.n315 0.444944
R2409 VDD.n315 VDD.n314 0.444944
R2410 VDD.n314 VDD.n313 0.444944
R2411 VDD.n313 VDD.n312 0.444944
R2412 VDD.n312 VDD.n311 0.444944
R2413 VDD.n311 VDD.n303 0.444944
R2414 VDD.n303 VDD.n302 0.444944
R2415 VDD.n302 VDD.n301 0.444944
R2416 VDD.n301 VDD.n293 0.444944
R2417 VDD.n368 VDD.n293 0.444944
R2418 VDD.n108 VDD.n38 0.444944
R2419 VDD.n108 VDD.n107 0.444944
R2420 VDD.n107 VDD.n106 0.444944
R2421 VDD.n106 VDD.n43 0.444944
R2422 VDD.n95 VDD.n43 0.444944
R2423 VDD.n95 VDD.n94 0.444944
R2424 VDD.n94 VDD.n93 0.444944
R2425 VDD.n93 VDD.n50 0.444944
R2426 VDD.n86 VDD.n50 0.444944
R2427 VDD.n86 VDD.n85 0.444944
R2428 VDD.n85 VDD.n84 0.444944
R2429 VDD.n84 VDD.n55 0.444944
R2430 VDD.n72 VDD.n55 0.444944
R2431 VDD.n72 VDD.n71 0.444944
R2432 VDD.n71 VDD.n70 0.444944
R2433 VDD.n282 VDD.n207 0.444944
R2434 VDD.n282 VDD.n281 0.444944
R2435 VDD.n281 VDD.n280 0.444944
R2436 VDD.n280 VDD.n212 0.444944
R2437 VDD.n268 VDD.n212 0.444944
R2438 VDD.n268 VDD.n267 0.444944
R2439 VDD.n267 VDD.n266 0.444944
R2440 VDD.n266 VDD.n218 0.444944
R2441 VDD.n256 VDD.n218 0.444944
R2442 VDD.n256 VDD.n255 0.444944
R2443 VDD.n255 VDD.n254 0.444944
R2444 VDD.n254 VDD.n223 0.444944
R2445 VDD.n241 VDD.n223 0.444944
R2446 VDD.n241 VDD.n240 0.444944
R2447 VDD.n240 VDD.n239 0.444944
R2448 VDD.n542 VDD.n461 0.379447
R2449 VDD.n25 VDD.n24 0.356056
R2450 VDD.n26 VDD.n25 0.356056
R2451 VDD.n23 VDD.n22 0.337342
R2452 VDD.n369 VDD.n368 0.311611
R2453 VDD.n115 VDD.n38 0.311611
R2454 VDD.n451 VDD.t285 0.228
R2455 VDD.n451 VDD.t283 0.228
R2456 VDD.n452 VDD.t289 0.228
R2457 VDD.n452 VDD.t287 0.228
R2458 VDD.n454 VDD.t386 0.228
R2459 VDD.n454 VDD.t384 0.228
R2460 VDD.n455 VDD.t390 0.228
R2461 VDD.n455 VDD.t388 0.228
R2462 VDD.n448 VDD.t394 0.228
R2463 VDD.n448 VDD.t392 0.228
R2464 VDD.n373 VDD.t75 0.228
R2465 VDD.n373 VDD.t77 0.228
R2466 VDD.n374 VDD.t71 0.228
R2467 VDD.n374 VDD.t69 0.228
R2468 VDD.n435 VDD.t47 0.228
R2469 VDD.n435 VDD.t73 0.228
R2470 VDD.n433 VDD.t65 0.228
R2471 VDD.n433 VDD.t67 0.228
R2472 VDD.n445 VDD.t273 0.228
R2473 VDD.n445 VDD.t271 0.228
R2474 VDD.n443 VDD.t561 0.228
R2475 VDD.n443 VDD.t275 0.228
R2476 VDD.n441 VDD.t565 0.228
R2477 VDD.n441 VDD.t563 0.228
R2478 VDD.n439 VDD.t269 0.228
R2479 VDD.n439 VDD.t267 0.228
R2480 VDD.n370 VDD.t259 0.228
R2481 VDD.n370 VDD.t261 0.228
R2482 VDD.n421 VDD.t87 0.228
R2483 VDD.n421 VDD.t81 0.228
R2484 VDD.n422 VDD.t253 0.228
R2485 VDD.n422 VDD.t255 0.228
R2486 VDD.n423 VDD.t251 0.228
R2487 VDD.n423 VDD.t250 0.228
R2488 VDD.n425 VDD.t248 0.228
R2489 VDD.n425 VDD.t226 0.228
R2490 VDD.n427 VDD.t244 0.228
R2491 VDD.n427 VDD.t246 0.228
R2492 VDD.n408 VDD.t79 0.228
R2493 VDD.n408 VDD.t83 0.228
R2494 VDD.n409 VDD.t225 0.228
R2495 VDD.n409 VDD.t236 0.228
R2496 VDD.n414 VDD.t234 0.228
R2497 VDD.n414 VDD.t228 0.228
R2498 VDD.n412 VDD.t232 0.228
R2499 VDD.n412 VDD.t233 0.228
R2500 VDD.n410 VDD.t221 0.228
R2501 VDD.n410 VDD.t230 0.228
R2502 VDD.n382 VDD.t495 0.228
R2503 VDD.n382 VDD.t493 0.228
R2504 VDD.n383 VDD.t491 0.228
R2505 VDD.n383 VDD.t489 0.228
R2506 VDD.n399 VDD.t545 0.228
R2507 VDD.n399 VDD.t543 0.228
R2508 VDD.n397 VDD.t539 0.228
R2509 VDD.n397 VDD.t537 0.228
R2510 VDD.n377 VDD.t63 0.228
R2511 VDD.n377 VDD.t49 0.228
R2512 VDD.n378 VDD.t59 0.228
R2513 VDD.n378 VDD.t61 0.228
R2514 VDD.n380 VDD.t55 0.228
R2515 VDD.n380 VDD.t51 0.228
R2516 VDD.n403 VDD.t53 0.228
R2517 VDD.n403 VDD.t57 0.228
R2518 VDD.n385 VDD.t223 0.228
R2519 VDD.n385 VDD.t257 0.228
R2520 VDD.n394 VDD.t398 0.228
R2521 VDD.n394 VDD.t396 0.228
R2522 VDD.n387 VDD.t281 0.228
R2523 VDD.n387 VDD.t279 0.228
R2524 VDD.n388 VDD.t402 0.228
R2525 VDD.n388 VDD.t400 0.228
R2526 VDD.n390 VDD.t406 0.228
R2527 VDD.n390 VDD.t404 0.228
R2528 VDD.n392 VDD.t153 0.228
R2529 VDD.n392 VDD.t151 0.228
R2530 VDD.n120 VDD.t364 0.228
R2531 VDD.n120 VDD.t362 0.228
R2532 VDD.n124 VDD.t368 0.228
R2533 VDD.n124 VDD.t366 0.228
R2534 VDD.n122 VDD.t356 0.228
R2535 VDD.n122 VDD.t354 0.228
R2536 VDD.n121 VDD.t360 0.228
R2537 VDD.n121 VDD.t358 0.228
R2538 VDD.n127 VDD.t352 0.228
R2539 VDD.n127 VDD.t350 0.228
R2540 VDD.n141 VDD.t458 0.228
R2541 VDD.n141 VDD.t460 0.228
R2542 VDD.n146 VDD.t454 0.228
R2543 VDD.n146 VDD.t456 0.228
R2544 VDD.n144 VDD.t450 0.228
R2545 VDD.n144 VDD.t452 0.228
R2546 VDD.n143 VDD.t448 0.228
R2547 VDD.n143 VDD.t438 0.228
R2548 VDD.n132 VDD.t422 0.228
R2549 VDD.n132 VDD.t420 0.228
R2550 VDD.n134 VDD.t481 0.228
R2551 VDD.n134 VDD.t424 0.228
R2552 VDD.n137 VDD.t485 0.228
R2553 VDD.n137 VDD.t483 0.228
R2554 VDD.n136 VDD.t417 0.228
R2555 VDD.n136 VDD.t415 0.228
R2556 VDD.n129 VDD.t209 0.228
R2557 VDD.n129 VDD.t211 0.228
R2558 VDD.n152 VDD.t203 0.228
R2559 VDD.n152 VDD.t205 0.228
R2560 VDD.n154 VDD.t201 0.228
R2561 VDD.n154 VDD.t197 0.228
R2562 VDD.n156 VDD.t171 0.228
R2563 VDD.n156 VDD.t199 0.228
R2564 VDD.n151 VDD.t294 0.228
R2565 VDD.n151 VDD.t297 0.228
R2566 VDD.n158 VDD.t193 0.228
R2567 VDD.n158 VDD.t195 0.228
R2568 VDD.n164 VDD.t295 0.228
R2569 VDD.n164 VDD.t296 0.228
R2570 VDD.n171 VDD.t181 0.228
R2571 VDD.n171 VDD.t183 0.228
R2572 VDD.n169 VDD.t177 0.228
R2573 VDD.n169 VDD.t179 0.228
R2574 VDD.n167 VDD.t167 0.228
R2575 VDD.n167 VDD.t165 0.228
R2576 VDD.n166 VDD.t173 0.228
R2577 VDD.n166 VDD.t175 0.228
R2578 VDD.n185 VDD.t138 0.228
R2579 VDD.n185 VDD.t136 0.228
R2580 VDD.n187 VDD.t551 0.228
R2581 VDD.n187 VDD.t549 0.228
R2582 VDD.n189 VDD.t92 0.228
R2583 VDD.n189 VDD.t90 0.228
R2584 VDD.n191 VDD.t111 0.228
R2585 VDD.n191 VDD.t109 0.228
R2586 VDD.n176 VDD.t444 0.228
R2587 VDD.n176 VDD.t446 0.228
R2588 VDD.n178 VDD.t440 0.228
R2589 VDD.n178 VDD.t442 0.228
R2590 VDD.n181 VDD.t434 0.228
R2591 VDD.n181 VDD.t436 0.228
R2592 VDD.n180 VDD.t432 0.228
R2593 VDD.n180 VDD.t430 0.228
R2594 VDD.n116 VDD.t169 0.228
R2595 VDD.n116 VDD.t207 0.228
R2596 VDD.n194 VDD.t343 0.228
R2597 VDD.n194 VDD.t374 0.228
R2598 VDD.n197 VDD.t380 0.228
R2599 VDD.n197 VDD.t378 0.228
R2600 VDD.n202 VDD.t143 0.228
R2601 VDD.n202 VDD.t382 0.228
R2602 VDD.n200 VDD.t147 0.228
R2603 VDD.n200 VDD.t145 0.228
R2604 VDD.n199 VDD.t155 0.228
R2605 VDD.n199 VDD.t149 0.228
R2606 VDD.n484 VDD.t339 0.228
R2607 VDD.n484 VDD.t11 0.228
R2608 VDD.n483 VDD.t13 0.228
R2609 VDD.n483 VDD.t341 0.228
R2610 VDD.n494 VDD.t98 0.228
R2611 VDD.n494 VDD.t96 0.228
R2612 VDD.n492 VDD.t473 0.228
R2613 VDD.n492 VDD.t479 0.228
R2614 VDD.n490 VDD.t477 0.228
R2615 VDD.n490 VDD.t475 0.228
R2616 VDD.n488 VDD.t471 0.228
R2617 VDD.n488 VDD.t476 0.228
R2618 VDD.n487 VDD.t467 0.228
R2619 VDD.n487 VDD.t469 0.228
R2620 VDD.n498 VDD.t122 0.228
R2621 VDD.n498 VDD.t128 0.228
R2622 VDD.n503 VDD.t124 0.228
R2623 VDD.n503 VDD.t126 0.228
R2624 VDD.n501 VDD.t116 0.228
R2625 VDD.n501 VDD.t120 0.228
R2626 VDD.n500 VDD.t114 0.228
R2627 VDD.n500 VDD.t118 0.228
R2628 VDD.n507 VDD.t22 0.228
R2629 VDD.n507 VDD.t3 0.228
R2630 VDD.n482 VDD.t17 0.228
R2631 VDD.n482 VDD.t15 0.228
R2632 VDD.n477 VDD.t554 0.228
R2633 VDD.n477 VDD.t24 0.228
R2634 VDD.n478 VDD.t263 0.228
R2635 VDD.n478 VDD.t9 0.228
R2636 VDD.n479 VDD.t277 0.228
R2637 VDD.n479 VDD.t557 0.228
R2638 VDD.n520 VDD.t524 0.228
R2639 VDD.n520 VDD.t525 0.228
R2640 VDD.n522 VDD.t522 0.228
R2641 VDD.n522 VDD.t511 0.228
R2642 VDD.n524 VDD.t520 0.228
R2643 VDD.n524 VDD.t521 0.228
R2644 VDD.n526 VDD.t515 0.228
R2645 VDD.n526 VDD.t518 0.228
R2646 VDD.n515 VDD.t531 0.228
R2647 VDD.n515 VDD.t513 0.228
R2648 VDD.n513 VDD.t529 0.228
R2649 VDD.n513 VDD.t530 0.228
R2650 VDD.n511 VDD.t527 0.228
R2651 VDD.n511 VDD.t528 0.228
R2652 VDD.n510 VDD.t516 0.228
R2653 VDD.n510 VDD.t526 0.228
R2654 VDD.n530 VDD.t100 0.228
R2655 VDD.n530 VDD.t132 0.228
R2656 VDD.n462 VDD.t497 0.228
R2657 VDD.n462 VDD.t496 0.228
R2658 VDD.n464 VDD.t45 0.228
R2659 VDD.n464 VDD.t569 0.228
R2660 VDD.n463 VDD.t19 0.228
R2661 VDD.n463 VDD.t43 0.228
R2662 VDD.n472 VDD.t320 0.228
R2663 VDD.n472 VDD.t321 0.228
R2664 VDD.n470 VDD.t301 0.228
R2665 VDD.n470 VDD.t319 0.228
R2666 VDD.n468 VDD.t318 0.228
R2667 VDD.n468 VDD.t303 0.228
R2668 VDD.n467 VDD.t305 0.228
R2669 VDD.n467 VDD.t317 0.228
R2670 VDD.n538 VDD.t310 0.228
R2671 VDD.n538 VDD.t316 0.228
R2672 VDD.n536 VDD.t312 0.228
R2673 VDD.n536 VDD.t314 0.228
R2674 VDD.n534 VDD.t308 0.228
R2675 VDD.n534 VDD.t311 0.228
R2676 VDD.n533 VDD.t306 0.228
R2677 VDD.n533 VDD.t299 0.228
R2678 VDD.n543 VDD.t130 0.228
R2679 VDD.n543 VDD.t465 0.228
R2680 VDD.n546 VDD.t38 0.228
R2681 VDD.n546 VDD.t40 0.228
R2682 VDD.n551 VDD.t34 0.228
R2683 VDD.n551 VDD.t36 0.228
R2684 VDD.n549 VDD.t32 0.228
R2685 VDD.n549 VDD.t28 0.228
R2686 VDD.n548 VDD.t26 0.228
R2687 VDD.n548 VDD.t30 0.228
R2688 VDD.n563 VDD.t499 0.228
R2689 VDD.n563 VDD.t498 0.228
R2690 VDD.n561 VDD.t331 0.228
R2691 VDD.n561 VDD.t337 0.228
R2692 VDD.n559 VDD.t333 0.228
R2693 VDD.n559 VDD.t335 0.228
R2694 VDD.n557 VDD.t327 0.228
R2695 VDD.n557 VDD.t329 0.228
R2696 VDD.n556 VDD.t325 0.228
R2697 VDD.n556 VDD.t323 0.228
R2698 VDD.n567 VDD.t5 0.228
R2699 VDD.n567 VDD.t509 0.228
R2700 VDD.n566 VDD.t567 0.228
R2701 VDD.n566 VDD.t102 0.228
R2702 VDD.n34 VDD.n33 0.227751
R2703 VDD.n396 VDD.n386 0.213658
R2704 VDD.n131 VDD.n130 0.213658
R2705 VDD.n459 VDD.n291 0.191026
R2706 VDD.n205 VDD.n37 0.191026
R2707 VDD.n406 VDD.n376 0.189974
R2708 VDD.n458 VDD.n450 0.189974
R2709 VDD.n457 VDD.n456 0.189974
R2710 VDD.n457 VDD.n453 0.189974
R2711 VDD.n442 VDD.n440 0.189974
R2712 VDD.n444 VDD.n442 0.189974
R2713 VDD.n446 VDD.n444 0.189974
R2714 VDD.n436 VDD.n434 0.189974
R2715 VDD.n429 VDD.n426 0.189974
R2716 VDD.n426 VDD.n424 0.189974
R2717 VDD.n413 VDD.n411 0.189974
R2718 VDD.n415 VDD.n413 0.189974
R2719 VDD.n416 VDD.n415 0.189974
R2720 VDD.n381 VDD.n379 0.189974
R2721 VDD.n400 VDD.n398 0.189974
R2722 VDD.n391 VDD.n389 0.189974
R2723 VDD.n204 VDD.n196 0.189974
R2724 VDD.n149 VDD.n119 0.189974
R2725 VDD.n125 VDD.n123 0.189974
R2726 VDD.n135 VDD.n133 0.189974
R2727 VDD.n147 VDD.n145 0.189974
R2728 VDD.n159 VDD.n157 0.189974
R2729 VDD.n157 VDD.n155 0.189974
R2730 VDD.n155 VDD.n153 0.189974
R2731 VDD.n170 VDD.n168 0.189974
R2732 VDD.n172 VDD.n170 0.189974
R2733 VDD.n179 VDD.n177 0.189974
R2734 VDD.n192 VDD.n190 0.189974
R2735 VDD.n190 VDD.n188 0.189974
R2736 VDD.n188 VDD.n186 0.189974
R2737 VDD.n203 VDD.n201 0.189974
R2738 VDD.n203 VDD.n198 0.189974
R2739 VDD.n491 VDD.n489 0.189974
R2740 VDD.n493 VDD.n491 0.189974
R2741 VDD.n504 VDD.n502 0.189974
R2742 VDD.n514 VDD.n512 0.189974
R2743 VDD.n516 VDD.n514 0.189974
R2744 VDD.n517 VDD.n516 0.189974
R2745 VDD.n527 VDD.n525 0.189974
R2746 VDD.n525 VDD.n523 0.189974
R2747 VDD.n523 VDD.n521 0.189974
R2748 VDD.n537 VDD.n535 0.189974
R2749 VDD.n539 VDD.n537 0.189974
R2750 VDD.n540 VDD.n539 0.189974
R2751 VDD.n471 VDD.n469 0.189974
R2752 VDD.n473 VDD.n471 0.189974
R2753 VDD.n474 VDD.n473 0.189974
R2754 VDD.n552 VDD.n550 0.189974
R2755 VDD.n560 VDD.n558 0.189974
R2756 VDD.n562 VDD.n560 0.189974
R2757 VDD.n28 VDD.n27 0.168921
R2758 VDD.n29 VDD.n28 0.168921
R2759 VDD.n30 VDD.n29 0.168921
R2760 VDD.n290 VDD.n207 0.133833
R2761 VDD.n401 VDD.n384 0.118921
R2762 VDD.n139 VDD.n138 0.118921
R2763 VDD.n573 VDD.n20 0.1105
R2764 VDD.n4 VDD.n2 0.1005
R2765 VDD.n8 VDD.n7 0.1005
R2766 VDD.n9 VDD.n1 0.1005
R2767 VDD.n13 VDD.n12 0.1005
R2768 VDD.n14 VDD.n0 0.1005
R2769 VDD.n18 VDD.n17 0.1005
R2770 VDD.n431 VDD.n420 0.0952368
R2771 VDD.n437 VDD.n436 0.0952368
R2772 VDD.n437 VDD.n375 0.0952368
R2773 VDD.n405 VDD.n404 0.0952368
R2774 VDD.n405 VDD.n381 0.0952368
R2775 VDD.n174 VDD.n163 0.0952368
R2776 VDD.n148 VDD.n147 0.0952368
R2777 VDD.n148 VDD.n142 0.0952368
R2778 VDD.n183 VDD.n182 0.0952368
R2779 VDD.n183 VDD.n179 0.0952368
R2780 VDD.n565 VDD.n555 0.0952368
R2781 VDD.n554 VDD.n545 0.0952368
R2782 VDD.n506 VDD.n497 0.0952368
R2783 VDD.n496 VDD.n486 0.0952368
R2784 VDD.n505 VDD.n504 0.0952368
R2785 VDD.n505 VDD.n499 0.0952368
R2786 VDD.n553 VDD.n552 0.0952368
R2787 VDD.n553 VDD.n547 0.0952368
R2788 VDD.n393 VDD.n391 0.0948023
R2789 VDD.n126 VDD.n125 0.0948023
R2790 VDD.n401 VDD.n400 0.0715526
R2791 VDD.n139 VDD.n135 0.0715526
R2792 VDD.n31 VDD.n30 0.0678684
R2793 VDD.n459 VDD.n369 0.0505
R2794 VDD.n205 VDD.n115 0.0505
R2795 VDD.n570 VDD.n290 0.0505
R2796 VDD.n570 VDD.n206 0.0331316
R2797 VDD VDD.n573 0.0205
R2798 VSS.n1171 VSS.n65 123500
R2799 VSS.n1067 VSS.t151 48139.4
R2800 VSS.n1068 VSS.n1067 47272.7
R2801 VSS.n1171 VSS.n1170 10017.1
R2802 VSS.n589 VSS.n65 9477.98
R2803 VSS.n1066 VSS.n318 5590
R2804 VSS.n1215 VSS.n92 4239.13
R2805 VSS.t74 VSS.t61 3033.33
R2806 VSS.n1045 VSS.n390 2405.38
R2807 VSS.n1100 VSS.n134 2325.9
R2808 VSS.t61 VSS.t68 1733.33
R2809 VSS.n1058 VSS.n323 1618.73
R2810 VSS.n322 VSS.t74 1462.5
R2811 VSS.t68 VSS.t128 1300
R2812 VSS.n356 VSS.n354 1266.62
R2813 VSS.t151 VSS.n1066 996.668
R2814 VSS.t71 VSS.t158 878.379
R2815 VSS.n356 VSS.n317 780
R2816 VSS.n1072 VSS.n313 780
R2817 VSS.n1070 VSS.n1069 780
R2818 VSS.n1072 VSS.n297 715
R2819 VSS.n1078 VSS.n313 651.125
R2820 VSS.n322 VSS.n318 617.5
R2821 VSS.n1193 VSS.n1192 515.874
R2822 VSS.n1215 VSS.n1214 515.874
R2823 VSS.n1215 VSS.n93 515.874
R2824 VSS.n1234 VSS.n67 515.874
R2825 VSS.n1068 VSS.n317 507
R2826 VSS.t158 VSS.t76 501.932
R2827 VSS.n1096 VSS.n134 465.916
R2828 VSS.n322 VSS.t71 423.505
R2829 VSS.t442 VSS.n1210 392.065
R2830 VSS.n1221 VSS.t436 392.065
R2831 VSS.t76 VSS.t215 376.449
R2832 VSS.t57 VSS.n113 371.43
R2833 VSS.t143 VSS.n1233 371.43
R2834 VSS.t260 VSS.t271 330.159
R2835 VSS.t112 VSS.t92 330.159
R2836 VSS.t2 VSS.n297 330.079
R2837 VSS.n375 VSS.n374 296.139
R2838 VSS.n377 VSS.n376 296.139
R2839 VSS.n380 VSS.n339 296.139
R2840 VSS.n386 VSS.n335 296.139
R2841 VSS.n1050 VSS.n389 296.139
R2842 VSS.n1049 VSS.n1048 296.139
R2843 VSS.n297 VSS.t226 279.298
R2844 VSS.n1069 VSS.n1068 273
R2845 VSS.n109 VSS.t258 268.255
R2846 VSS.n79 VSS.t88 268.255
R2847 VSS.n1199 VSS.t308 247.619
R2848 VSS.n1199 VSS.t49 247.619
R2849 VSS.n1232 VSS.t188 247.619
R2850 VSS.t460 VSS.n1232 247.619
R2851 VSS.n1192 VSS.n1191 237.303
R2852 VSS.n1247 VSS.n67 237.303
R2853 VSS.n1101 VSS.n1099 234.94
R2854 VSS.n1099 VSS.n297 215.362
R2855 VSS.n1108 VSS.n1107 211.446
R2856 VSS.n1057 VSS.n1056 204.55
R2857 VSS.n1101 VSS.n1100 180.12
R2858 VSS.n323 VSS.n322 178.814
R2859 VSS.n1210 VSS.t44 165.079
R2860 VSS.n1221 VSS.t156 165.079
R2861 VSS.n354 VSS.n353 163.127
R2862 VSS.n181 VSS.t512 152.136
R2863 VSS.n37 VSS.t509 152.136
R2864 VSS.n175 VSS.t511 149.395
R2865 VSS.n28 VSS.t510 149.395
R2866 VSS.n113 VSS.t310 144.445
R2867 VSS.t53 VSS.n109 144.445
R2868 VSS.n79 VSS.t182 144.445
R2869 VSS.n1233 VSS.t464 144.445
R2870 VSS.n1079 VSS.n1078 134.948
R2871 VSS.n1080 VSS.n1079 134.948
R2872 VSS.n1080 VSS.n309 134.948
R2873 VSS.n1086 VSS.n309 134.948
R2874 VSS.n1087 VSS.n1086 134.948
R2875 VSS.n1088 VSS.n1087 134.948
R2876 VSS.n1088 VSS.n304 134.948
R2877 VSS.n1094 VSS.n304 134.948
R2878 VSS.n1095 VSS.n1094 134.948
R2879 VSS.n1096 VSS.n1095 134.948
R2880 VSS.t283 VSS.t501 123.811
R2881 VSS.t21 VSS.t90 123.811
R2882 VSS.n1058 VSS.n1057 116.713
R2883 VSS.n353 VSS.n352 107.915
R2884 VSS.n374 VSS.n340 107.915
R2885 VSS.n378 VSS.n377 107.915
R2886 VSS.n380 VSS.n379 107.915
R2887 VSS.n387 VSS.n386 107.915
R2888 VSS.n389 VSS.n388 107.915
R2889 VSS.n1056 VSS.n326 107.915
R2890 VSS.n1057 VSS.n325 91.1502
R2891 VSS.n1136 VSS.n1135 91.0369
R2892 VSS.n670 VSS.n669 91.0369
R2893 VSS.n670 VSS.n564 91.0369
R2894 VSS.n633 VSS.n632 91.0369
R2895 VSS.n632 VSS.n581 91.0369
R2896 VSS.n1238 VSS.n64 87.5005
R2897 VSS.n1240 VSS.n68 87.5005
R2898 VSS.n69 VSS.n68 87.5005
R2899 VSS.n115 VSS.n114 87.5005
R2900 VSS.n114 VSS.n108 87.5005
R2901 VSS.n1200 VSS.n108 87.5005
R2902 VSS.n1200 VSS.n102 87.5005
R2903 VSS.n1204 VSS.n102 87.5005
R2904 VSS.n1204 VSS.n101 87.5005
R2905 VSS.n101 VSS.n96 87.5005
R2906 VSS.n96 VSS.n95 87.5005
R2907 VSS.n95 VSS.n94 87.5005
R2908 VSS.n94 VSS.n87 87.5005
R2909 VSS.n1222 VSS.n87 87.5005
R2910 VSS.n1222 VSS.n81 87.5005
R2911 VSS.n1226 VSS.n81 87.5005
R2912 VSS.n1226 VSS.n80 87.5005
R2913 VSS.n80 VSS.n75 87.5005
R2914 VSS.n75 VSS.n74 87.5005
R2915 VSS.n74 VSS.n73 87.5005
R2916 VSS.n73 VSS.n63 87.5005
R2917 VSS.n1182 VSS.n1181 87.5005
R2918 VSS.n1186 VSS.n1185 87.5005
R2919 VSS.n1194 VSS.n112 87.5005
R2920 VSS.n1194 VSS.n110 87.5005
R2921 VSS.n1198 VSS.n110 87.5005
R2922 VSS.n1198 VSS.n99 87.5005
R2923 VSS.n1205 VSS.n99 87.5005
R2924 VSS.n1205 VSS.n97 87.5005
R2925 VSS.n1209 VSS.n97 87.5005
R2926 VSS.n1209 VSS.n91 87.5005
R2927 VSS.n1216 VSS.n91 87.5005
R2928 VSS.n1216 VSS.n89 87.5005
R2929 VSS.n1220 VSS.n89 87.5005
R2930 VSS.n1220 VSS.n78 87.5005
R2931 VSS.n1227 VSS.n78 87.5005
R2932 VSS.n1227 VSS.n76 87.5005
R2933 VSS.n1231 VSS.n76 87.5005
R2934 VSS.n1231 VSS.n72 87.5005
R2935 VSS.n1235 VSS.n72 87.5005
R2936 VSS.n1235 VSS.n70 87.5005
R2937 VSS.n729 VSS.n541 87.5005
R2938 VSS.n675 VSS.n541 87.5005
R2939 VSS.n675 VSS.n561 87.5005
R2940 VSS.n671 VSS.n561 87.5005
R2941 VSS.n671 VSS.n563 87.5005
R2942 VSS.n661 VSS.n563 87.5005
R2943 VSS.n661 VSS.n568 87.5005
R2944 VSS.n657 VSS.n568 87.5005
R2945 VSS.n657 VSS.n570 87.5005
R2946 VSS.n651 VSS.n570 87.5005
R2947 VSS.n651 VSS.n575 87.5005
R2948 VSS.n647 VSS.n575 87.5005
R2949 VSS.n647 VSS.n577 87.5005
R2950 VSS.n631 VSS.n577 87.5005
R2951 VSS.n631 VSS.n582 87.5005
R2952 VSS.n627 VSS.n582 87.5005
R2953 VSS.n627 VSS.n584 87.5005
R2954 VSS.n618 VSS.n584 87.5005
R2955 VSS.n601 VSS.n597 87.5005
R2956 VSS.n605 VSS.n603 87.5005
R2957 VSS.n609 VSS.n594 87.5005
R2958 VSS.n612 VSS.n611 87.5005
R2959 VSS.n614 VSS.n612 87.5005
R2960 VSS.n705 VSS.n540 87.5005
R2961 VSS.n705 VSS.n553 87.5005
R2962 VSS.n668 VSS.n553 87.5005
R2963 VSS.n668 VSS.n565 87.5005
R2964 VSS.n664 VSS.n565 87.5005
R2965 VSS.n664 VSS.n663 87.5005
R2966 VSS.n663 VSS.n567 87.5005
R2967 VSS.n571 VSS.n567 87.5005
R2968 VSS.n640 VSS.n571 87.5005
R2969 VSS.n640 VSS.n574 87.5005
R2970 VSS.n644 VSS.n574 87.5005
R2971 VSS.n644 VSS.n578 87.5005
R2972 VSS.n634 VSS.n578 87.5005
R2973 VSS.n634 VSS.n580 87.5005
R2974 VSS.n586 VSS.n580 87.5005
R2975 VSS.n625 VSS.n586 87.5005
R2976 VSS.n625 VSS.n585 87.5005
R2977 VSS.n620 VSS.n585 87.5005
R2978 VSS.n713 VSS.n551 87.5005
R2979 VSS.n716 VSS.n715 87.5005
R2980 VSS.n720 VSS.n548 87.5005
R2981 VSS.n723 VSS.n722 87.5005
R2982 VSS.n131 VSS.n122 87.5005
R2983 VSS.n1142 VSS.n131 87.5005
R2984 VSS.n1142 VSS.n129 87.5005
R2985 VSS.n1137 VSS.n129 87.5005
R2986 VSS.n1137 VSS.n133 87.5005
R2987 VSS.n1128 VSS.n133 87.5005
R2988 VSS.n1128 VSS.n139 87.5005
R2989 VSS.n1124 VSS.n139 87.5005
R2990 VSS.n1124 VSS.n141 87.5005
R2991 VSS.n911 VSS.n141 87.5005
R2992 VSS.n911 VSS.n438 87.5005
R2993 VSS.n915 VSS.n438 87.5005
R2994 VSS.n915 VSS.n427 87.5005
R2995 VSS.n949 VSS.n427 87.5005
R2996 VSS.n949 VSS.n424 87.5005
R2997 VSS.n953 VSS.n424 87.5005
R2998 VSS.n953 VSS.n423 87.5005
R2999 VSS.n776 VSS.n423 87.5005
R3000 VSS.n517 VSS.n515 87.5005
R3001 VSS.n779 VSS.n517 87.5005
R3002 VSS.n783 VSS.n782 87.5005
R3003 VSS.n787 VSS.n786 87.5005
R3004 VSS.n789 VSS.n520 87.5005
R3005 VSS.n1148 VSS.n126 87.5005
R3006 VSS.n1144 VSS.n126 87.5005
R3007 VSS.n1144 VSS.n128 87.5005
R3008 VSS.n1134 VSS.n128 87.5005
R3009 VSS.n1134 VSS.n135 87.5005
R3010 VSS.n1130 VSS.n135 87.5005
R3011 VSS.n1130 VSS.n137 87.5005
R3012 VSS.n142 VSS.n137 87.5005
R3013 VSS.n908 VSS.n142 87.5005
R3014 VSS.n908 VSS.n439 87.5005
R3015 VSS.n903 VSS.n439 87.5005
R3016 VSS.n903 VSS.n437 87.5005
R3017 VSS.n899 VSS.n437 87.5005
R3018 VSS.n899 VSS.n429 87.5005
R3019 VSS.n896 VSS.n429 87.5005
R3020 VSS.n896 VSS.n418 87.5005
R3021 VSS.n801 VSS.n418 87.5005
R3022 VSS.n801 VSS.n513 87.5005
R3023 VSS.n1153 VSS.n1152 87.5005
R3024 VSS.n1157 VSS.n1156 87.5005
R3025 VSS.n1161 VSS.n1160 87.5005
R3026 VSS.n1165 VSS.n1164 87.5005
R3027 VSS.n1214 VSS.t161 82.5402
R3028 VSS.t24 VSS.n93 82.5402
R3029 VSS.n1102 VSS.n1098 77.0005
R3030 VSS.n1136 VSS.n134 72.8296
R3031 VSS.n330 VSS.n325 68.2505
R3032 VSS.n1249 VSS.n63 68.2505
R3033 VSS.n1178 VSS.n115 68.2505
R3034 VSS.n620 VSS.n588 68.2505
R3035 VSS.n709 VSS.n540 68.2505
R3036 VSS.n797 VSS.n513 68.2505
R3037 VSS.n1149 VSS.n1148 68.2505
R3038 VSS.t200 VSS.t400 65.5467
R3039 VSS.t15 VSS.n138 65.5467
R3040 VSS.t176 VSS.n564 65.5467
R3041 VSS.n633 VSS.t131 65.5467
R3042 VSS.t362 VSS.t394 65.5467
R3043 VSS.n1070 VSS.n297 65.0005
R3044 VSS.t296 VSS.n116 63.726
R3045 VSS.n619 VSS.t334 63.726
R3046 VSS.n1193 VSS.t39 61.9053
R3047 VSS.n1234 VSS.t32 61.9053
R3048 VSS.n1047 VSS.n1046 60.8596
R3049 VSS.n917 VSS.t169 60.0845
R3050 VSS.n1077 VSS.n314 59.5005
R3051 VSS.n942 VSS.n432 59.5005
R3052 VSS.n996 VSS.n397 59.5005
R3053 VSS.n505 VSS.n477 59.5005
R3054 VSS.n849 VSS.n478 59.5005
R3055 VSS.n1135 VSS.t410 56.4431
R3056 VSS.n669 VSS.t372 56.4431
R3057 VSS.t353 VSS.n581 56.4431
R3058 VSS.n352 VSS.t197 55.2129
R3059 VSS.t318 VSS.n340 55.2129
R3060 VSS.n375 VSS.t416 55.2129
R3061 VSS.n376 VSS.t355 55.2129
R3062 VSS.n378 VSS.t322 55.2129
R3063 VSS.n379 VSS.t63 55.2129
R3064 VSS.n339 VSS.t496 55.2129
R3065 VSS.t316 VSS.n335 55.2129
R3066 VSS.n387 VSS.t317 55.2129
R3067 VSS.n388 VSS.t319 55.2129
R3068 VSS.t320 VSS.n1050 55.2129
R3069 VSS.n1049 VSS.t321 55.2129
R3070 VSS.n1046 VSS.t485 55.2129
R3071 VSS.t352 VSS.n326 55.2129
R3072 VSS.n755 VSS.n398 54.6223
R3073 VSS.n746 VSS.n745 54.6223
R3074 VSS.t198 VSS.n554 54.6223
R3075 VSS.n373 VSS.n342 52.5005
R3076 VSS.n373 VSS.n341 52.5005
R3077 VSS.n341 VSS.n338 52.5005
R3078 VSS.n381 VSS.n338 52.5005
R3079 VSS.n381 VSS.n336 52.5005
R3080 VSS.n385 VSS.n336 52.5005
R3081 VSS.n385 VSS.n334 52.5005
R3082 VSS.n1051 VSS.n334 52.5005
R3083 VSS.n1051 VSS.n327 52.5005
R3084 VSS.n1055 VSS.n327 52.5005
R3085 VSS.n1055 VSS.n325 52.5005
R3086 VSS.n1073 VSS.n314 52.5005
R3087 VSS.n1073 VSS.n1071 52.5005
R3088 VSS.n1071 VSS.n316 52.5005
R3089 VSS.n359 VSS.n316 52.5005
R3090 VSS.n359 VSS.n357 52.5005
R3091 VSS.n363 VSS.n357 52.5005
R3092 VSS.n366 VSS.n365 52.5005
R3093 VSS.n1077 VSS.n312 52.5005
R3094 VSS.n1081 VSS.n312 52.5005
R3095 VSS.n1081 VSS.n310 52.5005
R3096 VSS.n1085 VSS.n310 52.5005
R3097 VSS.n1085 VSS.n308 52.5005
R3098 VSS.n1089 VSS.n308 52.5005
R3099 VSS.n1089 VSS.n305 52.5005
R3100 VSS.n1093 VSS.n305 52.5005
R3101 VSS.n1093 VSS.n302 52.5005
R3102 VSS.n1097 VSS.n302 52.5005
R3103 VSS.n1098 VSS.n1097 52.5005
R3104 VSS.n1102 VSS.n299 52.5005
R3105 VSS.n1106 VSS.n299 52.5005
R3106 VSS.n1106 VSS.n298 52.5005
R3107 VSS.n1064 VSS.n298 52.5005
R3108 VSS.n1060 VSS.n319 52.5005
R3109 VSS.n328 VSS.n321 52.5005
R3110 VSS.n1008 VSS.n1007 52.5005
R3111 VSS.n1009 VSS.n1008 52.5005
R3112 VSS.n1013 VSS.n1004 52.5005
R3113 VSS.n1016 VSS.n1015 52.5005
R3114 VSS.n1020 VSS.n1001 52.5005
R3115 VSS.n924 VSS.n292 52.5005
R3116 VSS.n928 VSS.n927 52.5005
R3117 VSS.n936 VSS.n935 52.5005
R3118 VSS.n940 VSS.n939 52.5005
R3119 VSS.n946 VSS.n432 52.5005
R3120 VSS.n946 VSS.n431 52.5005
R3121 VSS.n895 VSS.n431 52.5005
R3122 VSS.n895 VSS.n443 52.5005
R3123 VSS.n891 VSS.n443 52.5005
R3124 VSS.n891 VSS.n445 52.5005
R3125 VSS.n769 VSS.n445 52.5005
R3126 VSS.n774 VSS.n769 52.5005
R3127 VSS.n774 VSS.n764 52.5005
R3128 VSS.n764 VSS.n400 52.5005
R3129 VSS.n1033 VSS.n1032 52.5005
R3130 VSS.n1037 VSS.n1036 52.5005
R3131 VSS.n1039 VSS.n394 52.5005
R3132 VSS.n1043 VSS.n395 52.5005
R3133 VSS.n503 VSS.n489 52.5005
R3134 VSS.n499 VSS.n497 52.5005
R3135 VSS.n495 VSS.n492 52.5005
R3136 VSS.n869 VSS.n868 52.5005
R3137 VSS.n873 VSS.n462 52.5005
R3138 VSS.n876 VSS.n875 52.5005
R3139 VSS.n820 VSS.n818 52.5005
R3140 VSS.n816 VSS.n480 52.5005
R3141 VSS.n812 VSS.n810 52.5005
R3142 VSS.n837 VSS.n834 52.5005
R3143 VSS.n832 VSS.n823 52.5005
R3144 VSS.n828 VSS.n826 52.5005
R3145 VSS.n981 VSS.n407 52.5005
R3146 VSS.n981 VSS.n404 52.5005
R3147 VSS.n985 VSS.n404 52.5005
R3148 VSS.n985 VSS.n403 52.5005
R3149 VSS.n750 VSS.n403 52.5005
R3150 VSS.n750 VSS.n526 52.5005
R3151 VSS.n754 VSS.n526 52.5005
R3152 VSS.n754 VSS.n525 52.5005
R3153 VSS.n747 VSS.n525 52.5005
R3154 VSS.n747 VSS.n528 52.5005
R3155 VSS.n737 VSS.n528 52.5005
R3156 VSS.n737 VSS.n535 52.5005
R3157 VSS.n733 VSS.n535 52.5005
R3158 VSS.n733 VSS.n537 52.5005
R3159 VSS.n682 VSS.n537 52.5005
R3160 VSS.n698 VSS.n560 52.5005
R3161 VSS.n685 VSS.n678 52.5005
R3162 VSS.n688 VSS.n678 52.5005
R3163 VSS.n690 VSS.n680 52.5005
R3164 VSS.n681 VSS.n680 52.5005
R3165 VSS.n980 VSS.n411 52.5005
R3166 VSS.n980 VSS.n410 52.5005
R3167 VSS.n410 VSS.n401 52.5005
R3168 VSS.n762 VSS.n401 52.5005
R3169 VSS.n762 VSS.n522 52.5005
R3170 VSS.n757 VSS.n522 52.5005
R3171 VSS.n757 VSS.n756 52.5005
R3172 VSS.n756 VSS.n524 52.5005
R3173 VSS.n744 VSS.n524 52.5005
R3174 VSS.n744 VSS.n529 52.5005
R3175 VSS.n739 VSS.n529 52.5005
R3176 VSS.n739 VSS.n531 52.5005
R3177 VSS.n539 VSS.n531 52.5005
R3178 VSS.n703 VSS.n539 52.5005
R3179 VSS.n703 VSS.n555 52.5005
R3180 VSS.n960 VSS.n417 52.5005
R3181 VSS.n964 VSS.n963 52.5005
R3182 VSS.n968 VSS.n967 52.5005
R3183 VSS.n972 VSS.n958 52.5005
R3184 VSS.n909 VSS.t117 50.9809
R3185 VSS.n639 VSS.t304 50.9809
R3186 VSS.n1067 VSS.t2 50.7817
R3187 VSS.n368 VSS.n342 50.7505
R3188 VSS.n1190 VSS.n112 50.7505
R3189 VSS.n1245 VSS.n70 50.7505
R3190 VSS.n1111 VSS.n1110 50.7505
R3191 VSS.n1024 VSS.n1023 50.7505
R3192 VSS.n698 VSS.n555 50.7505
R3193 VSS.n975 VSS.n411 50.7505
R3194 VSS.n618 VSS.n591 50.7505
R3195 VSS.n729 VSS.n542 50.7505
R3196 VSS.n793 VSS.n776 50.7505
R3197 VSS.n1169 VSS.n122 50.7505
R3198 VSS.n1048 VSS.n1047 47.0565
R3199 VSS.n1190 VSS.n1175 43.7505
R3200 VSS.n850 VSS.n473 42.0005
R3201 VSS.n866 VSS.n456 42.0005
R3202 VSS.n808 VSS.n475 42.0005
R3203 VSS.n835 VSS.n455 42.0005
R3204 VSS.n695 VSS.n682 42.0005
R3205 VSS.n972 VSS.n407 42.0005
R3206 VSS.n1170 VSS.n116 41.8773
R3207 VSS.t139 VSS.n143 41.8773
R3208 VSS.n902 VSS.t493 41.8773
R3209 VSS.t119 VSS.n572 41.8773
R3210 VSS.n645 VSS.t124 41.8773
R3211 VSS.n619 VSS.n589 41.8773
R3212 VSS.t39 VSS.t35 41.2703
R3213 VSS.t35 VSS.t57 41.2703
R3214 VSS.t310 VSS.t312 41.2703
R3215 VSS.t312 VSS.t314 41.2703
R3216 VSS.t314 VSS.t308 41.2703
R3217 VSS.t49 VSS.t51 41.2703
R3218 VSS.t51 VSS.t47 41.2703
R3219 VSS.t47 VSS.t53 41.2703
R3220 VSS.t258 VSS.t264 41.2703
R3221 VSS.t264 VSS.t262 41.2703
R3222 VSS.t262 VSS.t159 41.2703
R3223 VSS.t159 VSS.t174 41.2703
R3224 VSS.t174 VSS.t267 41.2703
R3225 VSS.t269 VSS.t267 41.2703
R3226 VSS.t269 VSS.t271 41.2703
R3227 VSS.t273 VSS.t260 41.2703
R3228 VSS.t60 VSS.t273 41.2703
R3229 VSS.t59 VSS.t60 41.2703
R3230 VSS.t277 VSS.t279 41.2703
R3231 VSS.t279 VSS.t281 41.2703
R3232 VSS.t281 VSS.t283 41.2703
R3233 VSS.t501 VSS.t18 41.2703
R3234 VSS.t18 VSS.t44 41.2703
R3235 VSS.t156 VSS.t154 41.2703
R3236 VSS.t154 VSS.t21 41.2703
R3237 VSS.t90 VSS.t86 41.2703
R3238 VSS.t86 VSS.t37 41.2703
R3239 VSS.t37 VSS.t27 41.2703
R3240 VSS.t1 VSS.t0 41.2703
R3241 VSS.t0 VSS.t110 41.2703
R3242 VSS.t110 VSS.t112 41.2703
R3243 VSS.t94 VSS.t92 41.2703
R3244 VSS.t94 VSS.t96 41.2703
R3245 VSS.t98 VSS.t96 41.2703
R3246 VSS.t100 VSS.t98 41.2703
R3247 VSS.t102 VSS.t100 41.2703
R3248 VSS.t104 VSS.t102 41.2703
R3249 VSS.t88 VSS.t104 41.2703
R3250 VSS.t182 VSS.t184 41.2703
R3251 VSS.t184 VSS.t186 41.2703
R3252 VSS.t186 VSS.t188 41.2703
R3253 VSS.t41 VSS.t460 41.2703
R3254 VSS.t29 VSS.t41 41.2703
R3255 VSS.t464 VSS.t29 41.2703
R3256 VSS.t177 VSS.t143 41.2703
R3257 VSS.t32 VSS.t177 41.2703
R3258 VSS.n442 VSS.n441 39.9818
R3259 VSS.n322 VSS.n293 39.1571
R3260 VSS.t299 VSS.t488 36.4151
R3261 VSS.t481 VSS.t332 36.4151
R3262 VSS.t166 VSS.t192 36.4151
R3263 VSS.t472 VSS.t498 36.4151
R3264 VSS.n1023 VSS.n1022 35.0005
R3265 VSS.n400 VSS.n397 35.0005
R3266 VSS.n880 VSS.n421 35.0005
R3267 VSS.n448 VSS.n421 35.0005
R3268 VSS.n855 VSS.n448 35.0005
R3269 VSS.n855 VSS.n471 35.0005
R3270 VSS.n850 VSS.n471 35.0005
R3271 VSS.n456 VSS.n420 35.0005
R3272 VSS.n447 VSS.n420 35.0005
R3273 VSS.n470 VSS.n447 35.0005
R3274 VSS.n512 VSS.n470 35.0005
R3275 VSS.n512 VSS.n477 35.0005
R3276 VSS.n882 VSS.n422 35.0005
R3277 VSS.n886 VSS.n422 35.0005
R3278 VSS.n886 VSS.n449 35.0005
R3279 VSS.n804 VSS.n449 35.0005
R3280 VSS.n804 VSS.n475 35.0005
R3281 VSS.n455 VSS.n419 35.0005
R3282 VSS.n446 VSS.n419 35.0005
R3283 VSS.n857 VSS.n446 35.0005
R3284 VSS.n857 VSS.n469 35.0005
R3285 VSS.n849 VSS.n469 35.0005
R3286 VSS.n1123 VSS.t115 32.7736
R3287 VSS.n652 VSS.t306 32.7736
R3288 VSS.n1121 VSS.n144 29.6637
R3289 VSS.n655 VSS.n654 29.6637
R3290 VSS.n1213 VSS.n1212 29.6637
R3291 VSS.t243 VSS.n909 29.1322
R3292 VSS.n1122 VSS.n1121 28.4005
R3293 VSS.n654 VSS.n653 28.4005
R3294 VSS.n1212 VSS.n1211 28.4005
R3295 VSS.t224 VSS.n390 28.2218
R3296 VSS.n755 VSS.n92 27.3114
R3297 VSS.n745 VSS.n92 27.3114
R3298 VSS.n947 VSS.n430 26.5019
R3299 VSS.n725 VSS.n542 26.2505
R3300 VSS.n1169 VSS.n123 26.2505
R3301 VSS.t197 VSS.t466 25.097
R3302 VSS.t466 VSS.t318 25.097
R3303 VSS.t255 VSS.t416 25.097
R3304 VSS.t255 VSS.t355 25.097
R3305 VSS.t322 VSS.t350 25.097
R3306 VSS.t350 VSS.t63 25.097
R3307 VSS.t496 VSS.t46 25.097
R3308 VSS.t46 VSS.t316 25.097
R3309 VSS.t317 VSS.t130 25.097
R3310 VSS.t130 VSS.t319 25.097
R3311 VSS.t147 VSS.t320 25.097
R3312 VSS.t147 VSS.t321 25.097
R3313 VSS.t485 VSS.t150 25.097
R3314 VSS.t150 VSS.t352 25.097
R3315 VSS.n242 VSS.n241 24.6095
R3316 VSS.n244 VSS.n243 24.6095
R3317 VSS.n880 VSS.n458 24.5005
R3318 VSS.n882 VSS.n452 24.5005
R3319 VSS.n1122 VSS.t140 23.67
R3320 VSS.t492 VSS.n144 23.67
R3321 VSS.n881 VSS.n457 23.67
R3322 VSS.n746 VSS.t137 23.67
R3323 VSS.n655 VSS.t120 23.67
R3324 VSS.n653 VSS.t123 23.67
R3325 VSS.n1108 VSS.n293 23.4945
R3326 VSS.n977 VSS.n287 21.3764
R3327 VSS.n1120 VSS.n125 21.0663
R3328 VSS.n587 VSS.n573 21.0663
R3329 VSS.n1254 VSS.n1253 20.6555
R3330 VSS.n1191 VSS.n1171 20.6354
R3331 VSS.n100 VSS.t59 20.6354
R3332 VSS.n100 VSS.t277 20.6354
R3333 VSS.n1213 VSS.t442 20.6354
R3334 VSS.t161 VSS.n1213 20.6354
R3335 VSS.n1211 VSS.t24 20.6354
R3336 VSS.n1211 VSS.t436 20.6354
R3337 VSS.t27 VSS.n88 20.6354
R3338 VSS.n88 VSS.t1 20.6354
R3339 VSS.n1247 VSS.n65 20.6354
R3340 VSS.n994 VSS.t65 20.0285
R3341 VSS.n1114 VSS.n1113 19.8504
R3342 VSS.n1107 VSS.n297 19.5788
R3343 VSS.n186 VSS.n185 19.4957
R3344 VSS.n42 VSS.n41 19.4957
R3345 VSS.n370 VSS.n350 19.4846
R3346 VSS.n163 VSS.n162 19.3062
R3347 VSS.n19 VSS.n18 19.3062
R3348 VSS.n863 VSS.n862 19.1783
R3349 VSS.n864 VSS.n863 18.8227
R3350 VSS.n205 VSS.n204 18.5483
R3351 VSS.n282 VSS.n281 18.5483
R3352 VSS.n150 VSS.n149 18.4989
R3353 VSS.n6 VSS.n5 18.4989
R3354 VSS.n138 VSS.n134 18.2078
R3355 VSS.n1123 VSS.n1122 18.2078
R3356 VSS.n910 VSS.n144 18.2078
R3357 VSS.n436 VSS.n435 18.2078
R3358 VSS.n948 VSS.n947 18.2078
R3359 VSS.n656 VSS.n655 18.2078
R3360 VSS.n653 VSS.n652 18.2078
R3361 VSS.n156 VSS.n150 16.9831
R3362 VSS.n159 VSS.n158 16.9831
R3363 VSS.n193 VSS.n187 16.9831
R3364 VSS.n196 VSS.n195 16.9831
R3365 VSS.n202 VSS.n201 16.9831
R3366 VSS.n58 VSS.n57 16.9831
R3367 VSS.n52 VSS.n51 16.9831
R3368 VSS.n50 VSS.n43 16.9831
R3369 VSS.n15 VSS.n14 16.9831
R3370 VSS.n13 VSS.n6 16.9831
R3371 VSS.n533 VSS.t138 16.5691
R3372 VSS.t448 VSS.n986 16.3871
R3373 VSS.n738 VSS.t446 16.3871
R3374 VSS.t458 VSS.n545 16.3871
R3375 VSS.n457 VSS.n442 16.3123
R3376 VSS.n179 VSS.n178 15.8092
R3377 VSS.n35 VSS.n34 15.8092
R3378 VSS.n257 VSS.n246 15.2627
R3379 VSS.n215 VSS.n214 15.2222
R3380 VSS.n273 VSS.n272 15.2222
R3381 VSS.n344 VSS.t240 15.202
R3382 VSS.n1047 VSS.n1045 15.1168
R3383 VSS.t171 VSS.t439 14.5663
R3384 VSS.t43 VSS.t440 14.5663
R3385 VSS.t172 VSS.t254 14.5663
R3386 VSS.n344 VSS.t303 14.302
R3387 VSS.n345 VSS.t433 14.302
R3388 VSS.n346 VSS.t227 14.302
R3389 VSS.n347 VSS.t491 14.302
R3390 VSS.n348 VSS.t490 14.302
R3391 VSS.n349 VSS.t351 14.302
R3392 VSS.n210 VSS.n206 13.793
R3393 VSS.n278 VSS.n274 13.793
R3394 VSS.n559 VSS.n558 13.5139
R3395 VSS.n416 VSS.n415 13.5139
R3396 VSS.n1252 VSS.n1251 13.5005
R3397 VSS.n219 VSS.n216 13.2657
R3398 VSS.n262 VSS.n259 13.2657
R3399 VSS.n225 VSS.n217 12.9149
R3400 VSS.n268 VSS.n260 12.9149
R3401 VSS.t251 VSS.n474 12.5635
R3402 VSS.n249 VSS.n248 12.4151
R3403 VSS.n992 VSS.t149 11.6532
R3404 VSS.t388 VSS.n538 11.1069
R3405 VSS.n233 VSS.n227 11.0126
R3406 VSS.n910 VSS.t249 10.9249
R3407 VSS.t252 VSS.t494 10.9249
R3408 VSS.t438 VSS.t142 10.9249
R3409 VSS.t125 VSS.t441 10.9249
R3410 VSS.t253 VSS.t122 10.9249
R3411 VSS.t378 VSS.n554 10.9249
R3412 VSS.n656 VSS.t216 10.9249
R3413 VSS.n211 VSS.n210 10.7222
R3414 VSS.n279 VSS.n278 10.7222
R3415 VSS.n840 VSS.n839 10.2705
R3416 VSS.n846 VSS.n845 10.2705
R3417 VSS.n482 VSS.n465 10.2705
R3418 VSS.n488 VSS.n487 10.2705
R3419 VSS.n181 VSS.n180 9.98011
R3420 VSS.n37 VSS.n36 9.98011
R3421 VSS.n231 VSS.n230 9.98011
R3422 VSS.n888 VSS.t421 9.28621
R3423 VSS.n768 VSS.t503 9.10414
R3424 VSS.t181 VSS.n476 9.10414
R3425 VSS.t173 VSS.n763 9.10414
R3426 VSS.n532 VSS.t43 9.10414
R3427 VSS.n732 VSS.t172 9.10414
R3428 VSS.n226 VSS.n225 8.76572
R3429 VSS.n269 VSS.n268 8.76572
R3430 VSS.n174 VSS.n164 8.57007
R3431 VSS.n182 VSS.n181 8.57007
R3432 VSS.n27 VSS.n20 8.57007
R3433 VSS.n38 VSS.n37 8.57007
R3434 VSS.n435 VSS.n430 8.29465
R3435 VSS.n231 VSS.n229 7.51148
R3436 VSS.n428 VSS.t285 7.32154
R3437 VSS.t256 VSS.n442 7.32154
R3438 VSS.t294 VSS.t296 7.28341
R3439 VSS.t206 VSS.t294 7.28341
R3440 VSS.t204 VSS.t206 7.28341
R3441 VSS.t202 VSS.t200 7.28341
R3442 VSS.t400 VSS.t408 7.28341
R3443 VSS.t408 VSS.t406 7.28341
R3444 VSS.t402 VSS.t404 7.28341
R3445 VSS.t414 VSS.t402 7.28341
R3446 VSS.t412 VSS.t414 7.28341
R3447 VSS.t410 VSS.t412 7.28341
R3448 VSS.t153 VSS.t15 7.28341
R3449 VSS.t507 VSS.t153 7.28341
R3450 VSS.t179 VSS.t507 7.28341
R3451 VSS.t152 VSS.t434 7.28341
R3452 VSS.t488 VSS.t475 7.28341
R3453 VSS.t298 VSS.t299 7.28341
R3454 VSS.t323 VSS.t298 7.28341
R3455 VSS.t140 VSS.t139 7.28341
R3456 VSS.t117 VSS.t115 7.28341
R3457 VSS.t228 VSS.t243 7.28341
R3458 VSS.t230 VSS.t228 7.28341
R3459 VSS.t232 VSS.t230 7.28341
R3460 VSS.t234 VSS.t232 7.28341
R3461 VSS.t236 VSS.t234 7.28341
R3462 VSS.t238 VSS.t236 7.28341
R3463 VSS.t249 VSS.t238 7.28341
R3464 VSS.t493 VSS.t492 7.28341
R3465 VSS.t487 VSS.t486 7.28341
R3466 VSS.t486 VSS.t481 7.28341
R3467 VSS.t332 VSS.t330 7.28341
R3468 VSS.t508 VSS.t497 7.28341
R3469 VSS.t17 VSS.t16 7.28341
R3470 VSS.t55 VSS.t17 7.28341
R3471 VSS.t169 VSS.t55 7.28341
R3472 VSS.t344 VSS.t390 7.28341
R3473 VSS.t423 VSS.t421 7.28341
R3474 VSS.t425 VSS.t423 7.28341
R3475 VSS.t450 VSS.t448 7.28341
R3476 VSS.t173 VSS.t454 7.28341
R3477 VSS.t138 VSS.t137 7.28341
R3478 VSS.t126 VSS.t125 7.28341
R3479 VSS.t444 VSS.t456 7.28341
R3480 VSS.t456 VSS.t458 7.28341
R3481 VSS.t288 VSS.t290 7.28341
R3482 VSS.t286 VSS.t198 7.28341
R3483 VSS.t376 VSS.t378 7.28341
R3484 VSS.t368 VSS.t370 7.28341
R3485 VSS.t366 VSS.t368 7.28341
R3486 VSS.t364 VSS.t366 7.28341
R3487 VSS.t372 VSS.t364 7.28341
R3488 VSS.t31 VSS.t176 7.28341
R3489 VSS.t127 VSS.t31 7.28341
R3490 VSS.t163 VSS.t127 7.28341
R3491 VSS.t129 VSS.t114 7.28341
R3492 VSS.t192 VSS.t194 7.28341
R3493 VSS.t165 VSS.t166 7.28341
R3494 VSS.t180 VSS.t165 7.28341
R3495 VSS.t120 VSS.t119 7.28341
R3496 VSS.t216 VSS.t3 7.28341
R3497 VSS.t3 VSS.t9 7.28341
R3498 VSS.t9 VSS.t11 7.28341
R3499 VSS.t11 VSS.t7 7.28341
R3500 VSS.t7 VSS.t5 7.28341
R3501 VSS.t5 VSS.t13 7.28341
R3502 VSS.t13 VSS.t224 7.28341
R3503 VSS.t304 VSS.t306 7.28341
R3504 VSS.t124 VSS.t123 7.28341
R3505 VSS.t499 VSS.t500 7.28341
R3506 VSS.t498 VSS.t499 7.28341
R3507 VSS.t470 VSS.t472 7.28341
R3508 VSS.t302 VSS.t145 7.28341
R3509 VSS.t38 VSS.t418 7.28341
R3510 VSS.t34 VSS.t38 7.28341
R3511 VSS.t131 VSS.t34 7.28341
R3512 VSS.t386 VSS.t353 7.28341
R3513 VSS.t384 VSS.t386 7.28341
R3514 VSS.t382 VSS.t384 7.28341
R3515 VSS.t380 VSS.t382 7.28341
R3516 VSS.t396 VSS.t398 7.28341
R3517 VSS.t394 VSS.t396 7.28341
R3518 VSS.t360 VSS.t362 7.28341
R3519 VSS.t356 VSS.t358 7.28341
R3520 VSS.t336 VSS.t356 7.28341
R3521 VSS.t334 VSS.t336 7.28341
R3522 VSS.n1118 VSS.n1117 7.1555
R3523 VSS.n888 VSS.n887 7.10134
R3524 VSS.n766 VSS.n476 7.10134
R3525 VSS.n989 VSS.n399 7.10134
R3526 VSS.n533 VSS.n532 7.10134
R3527 VSS.n732 VSS.n538 7.10134
R3528 VSS.n1212 VSS.n60 6.8599
R3529 VSS.n919 VSS.t72 6.57557
R3530 VSS.n991 VSS.t171 6.55512
R3531 VSS.n844 VSS.n841 6.5388
R3532 VSS.n843 VSS.n842 6.5388
R3533 VSS.n486 VSS.n483 6.5388
R3534 VSS.n485 VSS.n484 6.5388
R3535 VSS.n932 VSS.n930 6.49615
R3536 VSS.n1029 VSS.t85 6.45713
R3537 VSS.n240 VSS.n239 6.41789
R3538 VSS.n258 VSS.n257 6.41789
R3539 VSS.n249 VSS.n245 6.41789
R3540 VSS.n1028 VSS.n1027 6.41078
R3541 VSS.n558 VSS.n556 6.38826
R3542 VSS.n415 VSS.n414 6.38826
R3543 VSS.n558 VSS.n557 6.38502
R3544 VSS.n415 VSS.n413 6.38502
R3545 VSS.n932 VSS.n931 6.31615
R3546 VSS.n919 VSS.n918 6.29483
R3547 VSS.n1028 VSS.n1026 6.29483
R3548 VSS.n921 VSS.n920 6.29333
R3549 VSS.n933 VSS.n932 6.278
R3550 VSS.n187 VSS.n186 6.20576
R3551 VSS.n43 VSS.n42 6.20576
R3552 VSS.n453 VSS.t342 6.19098
R3553 VSS.n1118 VSS.n282 6.1385
R3554 VSS.n1253 VSS.n1252 5.8145
R3555 VSS.n248 VSS.t45 5.7796
R3556 VSS.n922 VSS.n921 5.6555
R3557 VSS.n987 VSS.t450 5.64476
R3558 VSS.t142 VSS.n988 5.64476
R3559 VSS.n990 VSS.t438 5.64476
R3560 VSS.t441 VSS.n534 5.64476
R3561 VSS.n731 VSS.t253 5.64476
R3562 VSS.n204 VSS.t33 5.63749
R3563 VSS.n281 VSS.t58 5.63749
R3564 VSS.n1030 VSS.n1029 5.5955
R3565 VSS.n229 VSS.t22 5.59012
R3566 VSS.n147 VSS.n145 5.57485
R3567 VSS.n153 VSS.n151 5.57485
R3568 VSS.n162 VSS.n160 5.57485
R3569 VSS.n167 VSS.n165 5.57485
R3570 VSS.n171 VSS.n169 5.57485
R3571 VSS.n190 VSS.n188 5.57485
R3572 VSS.n199 VSS.n197 5.57485
R3573 VSS.n185 VSS.n183 5.57485
R3574 VSS.n56 VSS.n54 5.57485
R3575 VSS.n47 VSS.n45 5.57485
R3576 VSS.n41 VSS.n39 5.57485
R3577 VSS.n25 VSS.n23 5.57485
R3578 VSS.n31 VSS.n29 5.57485
R3579 VSS.n10 VSS.n8 5.57485
R3580 VSS.n4 VSS.n2 5.57485
R3581 VSS.n18 VSS.n16 5.57485
R3582 VSS.n222 VSS.n220 5.57485
R3583 VSS.n229 VSS.n228 5.57485
R3584 VSS.n236 VSS.n234 5.57485
R3585 VSS.n214 VSS.n213 5.57485
R3586 VSS.n209 VSS.n208 5.57485
R3587 VSS.n265 VSS.n263 5.57485
R3588 VSS.n255 VSS.n253 5.57485
R3589 VSS.n272 VSS.n271 5.57485
R3590 VSS.n277 VSS.n276 5.57485
R3591 VSS.n204 VSS.n203 5.52748
R3592 VSS.n281 VSS.n280 5.52748
R3593 VSS.n149 VSS.n148 5.48011
R3594 VSS.n173 VSS.n172 5.48011
R3595 VSS.n201 VSS.n200 5.48011
R3596 VSS.n57 VSS.n53 5.48011
R3597 VSS.n26 VSS.n22 5.48011
R3598 VSS.n5 VSS.n1 5.48011
R3599 VSS.n130 VSS.t204 5.46268
R3600 VSS.n1143 VSS.t404 5.46268
R3601 VSS.t479 VSS.t152 5.46268
R3602 VSS.t477 VSS.t164 5.46268
R3603 VSS.t475 VSS.t56 5.46268
R3604 VSS.t330 VSS.t474 5.46268
R3605 VSS.t328 VSS.t170 5.46268
R3606 VSS.t300 VSS.t508 5.46268
R3607 VSS.n917 VSS.n436 5.46268
R3608 VSS.t342 VSS.t20 5.46268
R3609 VSS.n954 VSS.t340 5.46268
R3610 VSS.n973 VSS.t326 5.46268
R3611 VSS.n890 VSS.t133 5.46268
R3612 VSS.n887 VSS.t134 5.46268
R3613 VSS.n856 VSS.t425 5.46268
R3614 VSS.t209 VSS.t23 5.46268
R3615 VSS.n795 VSS.t454 5.46268
R3616 VSS.n763 VSS.t141 5.46268
R3617 VSS.n738 VSS.t126 5.46268
R3618 VSS.n546 VSS.t446 5.46268
R3619 VSS.n545 VSS.t121 5.46268
R3620 VSS.t66 VSS.t388 5.46268
R3621 VSS.t67 VSS.t292 5.46268
R3622 VSS.n704 VSS.t288 5.46268
R3623 VSS.n697 VSS.t376 5.46268
R3624 VSS.n676 VSS.t370 5.46268
R3625 VSS.t348 VSS.t129 5.46268
R3626 VSS.t346 VSS.t420 5.46268
R3627 VSS.t194 VSS.t467 5.46268
R3628 VSS.t146 VSS.t470 5.46268
R3629 VSS.t417 VSS.t468 5.46268
R3630 VSS.t145 VSS.t167 5.46268
R3631 VSS.n626 VSS.t380 5.46268
R3632 VSS.t358 VSS.n590 5.46268
R3633 VSS.n147 VSS.n146 5.38537
R3634 VSS.n153 VSS.n152 5.38537
R3635 VSS.n155 VSS.n154 5.38537
R3636 VSS.n158 VSS.n157 5.38537
R3637 VSS.n162 VSS.n161 5.38537
R3638 VSS.n167 VSS.n166 5.38537
R3639 VSS.n176 VSS.n168 5.38537
R3640 VSS.n171 VSS.n170 5.38537
R3641 VSS.n178 VSS.n177 5.38537
R3642 VSS.n190 VSS.n189 5.38537
R3643 VSS.n192 VSS.n191 5.38537
R3644 VSS.n195 VSS.n194 5.38537
R3645 VSS.n199 VSS.n198 5.38537
R3646 VSS.n185 VSS.n184 5.38537
R3647 VSS.n56 VSS.n55 5.38537
R3648 VSS.n51 VSS.n44 5.38537
R3649 VSS.n49 VSS.n48 5.38537
R3650 VSS.n47 VSS.n46 5.38537
R3651 VSS.n41 VSS.n40 5.38537
R3652 VSS.n34 VSS.n21 5.38537
R3653 VSS.n25 VSS.n24 5.38537
R3654 VSS.n33 VSS.n32 5.38537
R3655 VSS.n31 VSS.n30 5.38537
R3656 VSS.n14 VSS.n7 5.38537
R3657 VSS.n12 VSS.n11 5.38537
R3658 VSS.n10 VSS.n9 5.38537
R3659 VSS.n4 VSS.n3 5.38537
R3660 VSS.n18 VSS.n17 5.38537
R3661 VSS.n219 VSS.n218 5.38537
R3662 VSS.n224 VSS.n223 5.38537
R3663 VSS.n222 VSS.n221 5.38537
R3664 VSS.n233 VSS.n232 5.38537
R3665 VSS.n238 VSS.n237 5.38537
R3666 VSS.n236 VSS.n235 5.38537
R3667 VSS.n214 VSS.n212 5.38537
R3668 VSS.n209 VSS.n207 5.38537
R3669 VSS.n262 VSS.n261 5.38537
R3670 VSS.n267 VSS.n266 5.38537
R3671 VSS.n265 VSS.n264 5.38537
R3672 VSS.n251 VSS.n250 5.38537
R3673 VSS.n248 VSS.n247 5.38537
R3674 VSS.n256 VSS.n252 5.38537
R3675 VSS.n255 VSS.n254 5.38537
R3676 VSS.n272 VSS.n270 5.38537
R3677 VSS.n277 VSS.n275 5.38537
R3678 VSS.n239 VSS.n231 5.28311
R3679 VSS.t324 VSS.n889 5.28061
R3680 VSS.t211 VSS.n408 5.28061
R3681 VSS.n369 VSS.n368 5.2005
R3682 VSS.n366 VSS.n351 5.2005
R3683 VSS.n365 VSS.n355 5.2005
R3684 VSS.n363 VSS.n362 5.2005
R3685 VSS.n357 VSS.n356 5.2005
R3686 VSS.n361 VSS.n357 5.2005
R3687 VSS.n359 VSS.n317 5.2005
R3688 VSS.n360 VSS.n359 5.2005
R3689 VSS.n1069 VSS.n316 5.2005
R3690 VSS.n358 VSS.n316 5.2005
R3691 VSS.n1071 VSS.n1070 5.2005
R3692 VSS.n1071 VSS.n315 5.2005
R3693 VSS.n1073 VSS.n1072 5.2005
R3694 VSS.n1074 VSS.n1073 5.2005
R3695 VSS.n314 VSS.n313 5.2005
R3696 VSS.n1075 VSS.n314 5.2005
R3697 VSS.n1100 VSS.n1098 5.2005
R3698 VSS.n1098 VSS.n301 5.2005
R3699 VSS.n1097 VSS.n1096 5.2005
R3700 VSS.n1097 VSS.n303 5.2005
R3701 VSS.n1095 VSS.n302 5.2005
R3702 VSS.n306 VSS.n302 5.2005
R3703 VSS.n1094 VSS.n1093 5.2005
R3704 VSS.n1093 VSS.n1092 5.2005
R3705 VSS.n305 VSS.n304 5.2005
R3706 VSS.n1091 VSS.n305 5.2005
R3707 VSS.n1089 VSS.n1088 5.2005
R3708 VSS.n1090 VSS.n1089 5.2005
R3709 VSS.n1087 VSS.n308 5.2005
R3710 VSS.n308 VSS.n307 5.2005
R3711 VSS.n1086 VSS.n1085 5.2005
R3712 VSS.n1085 VSS.n1084 5.2005
R3713 VSS.n310 VSS.n309 5.2005
R3714 VSS.n1083 VSS.n310 5.2005
R3715 VSS.n1081 VSS.n1080 5.2005
R3716 VSS.n1082 VSS.n1081 5.2005
R3717 VSS.n1079 VSS.n312 5.2005
R3718 VSS.n312 VSS.n311 5.2005
R3719 VSS.n1078 VSS.n1077 5.2005
R3720 VSS.n1077 VSS.n1076 5.2005
R3721 VSS.n331 VSS.n330 5.2005
R3722 VSS.n329 VSS.n328 5.2005
R3723 VSS.n321 VSS.n320 5.2005
R3724 VSS.n1061 VSS.n1060 5.2005
R3725 VSS.n1062 VSS.n319 5.2005
R3726 VSS.n1064 VSS.n1063 5.2005
R3727 VSS.n298 VSS.n293 5.2005
R3728 VSS.n300 VSS.n298 5.2005
R3729 VSS.n1107 VSS.n1106 5.2005
R3730 VSS.n1106 VSS.n1105 5.2005
R3731 VSS.n1099 VSS.n299 5.2005
R3732 VSS.n1104 VSS.n299 5.2005
R3733 VSS.n1102 VSS.n1101 5.2005
R3734 VSS.n1103 VSS.n1102 5.2005
R3735 VSS.n353 VSS.n342 5.2005
R3736 VSS.n371 VSS.n342 5.2005
R3737 VSS.n374 VSS.n373 5.2005
R3738 VSS.n373 VSS.n372 5.2005
R3739 VSS.n341 VSS.t255 5.2005
R3740 VSS.n343 VSS.n341 5.2005
R3741 VSS.n377 VSS.n338 5.2005
R3742 VSS.n338 VSS.n337 5.2005
R3743 VSS.n381 VSS.n380 5.2005
R3744 VSS.n382 VSS.n381 5.2005
R3745 VSS.t46 VSS.n336 5.2005
R3746 VSS.n383 VSS.n336 5.2005
R3747 VSS.n386 VSS.n385 5.2005
R3748 VSS.n385 VSS.n384 5.2005
R3749 VSS.n389 VSS.n334 5.2005
R3750 VSS.n334 VSS.n333 5.2005
R3751 VSS.n1051 VSS.t147 5.2005
R3752 VSS.n1052 VSS.n1051 5.2005
R3753 VSS.n1048 VSS.n327 5.2005
R3754 VSS.n1053 VSS.n327 5.2005
R3755 VSS.n1056 VSS.n1055 5.2005
R3756 VSS.n1055 VSS.n1054 5.2005
R3757 VSS.n332 VSS.n325 5.2005
R3758 VSS.n1023 VSS.n323 5.2005
R3759 VSS.n1023 VSS.n999 5.2005
R3760 VSS.n1022 VSS.n1000 5.2005
R3761 VSS.n1020 VSS.n1019 5.2005
R3762 VSS.n1018 VSS.n1001 5.2005
R3763 VSS.n1017 VSS.n1016 5.2005
R3764 VSS.n1015 VSS.n1002 5.2005
R3765 VSS.n1013 VSS.n1012 5.2005
R3766 VSS.n1011 VSS.n1004 5.2005
R3767 VSS.n1010 VSS.n1009 5.2005
R3768 VSS.n1025 VSS.n1024 5.2005
R3769 VSS.n1032 VSS.n1031 5.2005
R3770 VSS.n1034 VSS.n1033 5.2005
R3771 VSS.n1036 VSS.n1035 5.2005
R3772 VSS.n1038 VSS.n1037 5.2005
R3773 VSS.n1040 VSS.n1039 5.2005
R3774 VSS.n1041 VSS.n394 5.2005
R3775 VSS.n1043 VSS.n1042 5.2005
R3776 VSS.n775 VSS.n513 5.2005
R3777 VSS.n799 VSS.n513 5.2005
R3778 VSS.t23 VSS.n801 5.2005
R3779 VSS.n801 VSS.n800 5.2005
R3780 VSS.n954 VSS.n418 5.2005
R3781 VSS.n440 VSS.n418 5.2005
R3782 VSS.n896 VSS.t256 5.2005
R3783 VSS.n897 VSS.n896 5.2005
R3784 VSS.n948 VSS.n429 5.2005
R3785 VSS.n898 VSS.n429 5.2005
R3786 VSS.n899 VSS.n436 5.2005
R3787 VSS.n900 VSS.n899 5.2005
R3788 VSS.n916 VSS.n437 5.2005
R3789 VSS.n901 VSS.n437 5.2005
R3790 VSS.n903 VSS.n902 5.2005
R3791 VSS.n904 VSS.n903 5.2005
R3792 VSS.n910 VSS.n439 5.2005
R3793 VSS.n905 VSS.n439 5.2005
R3794 VSS.n909 VSS.n908 5.2005
R3795 VSS.n908 VSS.n907 5.2005
R3796 VSS.n1123 VSS.n142 5.2005
R3797 VSS.n906 VSS.n142 5.2005
R3798 VSS.n143 VSS.n137 5.2005
R3799 VSS.n137 VSS.n136 5.2005
R3800 VSS.n1130 VSS.n1129 5.2005
R3801 VSS.n1131 VSS.n1130 5.2005
R3802 VSS.n138 VSS.n135 5.2005
R3803 VSS.n1132 VSS.n135 5.2005
R3804 VSS.n1136 VSS.n1134 5.2005
R3805 VSS.n1134 VSS.n1133 5.2005
R3806 VSS.n1135 VSS.n128 5.2005
R3807 VSS.n128 VSS.n127 5.2005
R3808 VSS.n1144 VSS.n1143 5.2005
R3809 VSS.n1145 VSS.n1144 5.2005
R3810 VSS.n130 VSS.n126 5.2005
R3811 VSS.n1146 VSS.n126 5.2005
R3812 VSS.n1148 VSS.n116 5.2005
R3813 VSS.n1148 VSS.n1147 5.2005
R3814 VSS.n1170 VSS.n1169 5.2005
R3815 VSS.n1169 VSS.n1168 5.2005
R3816 VSS.n1167 VSS.n123 5.2005
R3817 VSS.n1166 VSS.n1165 5.2005
R3818 VSS.n1164 VSS.n1163 5.2005
R3819 VSS.n1162 VSS.n1161 5.2005
R3820 VSS.n1160 VSS.n1159 5.2005
R3821 VSS.n1158 VSS.n1157 5.2005
R3822 VSS.n1156 VSS.n1155 5.2005
R3823 VSS.n1154 VSS.n1153 5.2005
R3824 VSS.n1152 VSS.n1151 5.2005
R3825 VSS.n1150 VSS.n1149 5.2005
R3826 VSS.n798 VSS.n797 5.2005
R3827 VSS.n515 VSS.n514 5.2005
R3828 VSS.n795 VSS.n517 5.2005
R3829 VSS.n778 VSS.n517 5.2005
R3830 VSS.n780 VSS.n779 5.2005
R3831 VSS.n782 VSS.n781 5.2005
R3832 VSS.n784 VSS.n783 5.2005
R3833 VSS.n786 VSS.n785 5.2005
R3834 VSS.n788 VSS.n787 5.2005
R3835 VSS.n790 VSS.n789 5.2005
R3836 VSS.n791 VSS.n520 5.2005
R3837 VSS.n793 VSS.n792 5.2005
R3838 VSS.n776 VSS.n775 5.2005
R3839 VSS.n777 VSS.n776 5.2005
R3840 VSS.t23 VSS.n423 5.2005
R3841 VSS.n425 VSS.n423 5.2005
R3842 VSS.n954 VSS.n953 5.2005
R3843 VSS.n953 VSS.n952 5.2005
R3844 VSS.t256 VSS.n424 5.2005
R3845 VSS.n951 VSS.n424 5.2005
R3846 VSS.n949 VSS.n948 5.2005
R3847 VSS.n950 VSS.n949 5.2005
R3848 VSS.n436 VSS.n427 5.2005
R3849 VSS.n427 VSS.n426 5.2005
R3850 VSS.n916 VSS.n915 5.2005
R3851 VSS.n915 VSS.n914 5.2005
R3852 VSS.n902 VSS.n438 5.2005
R3853 VSS.n913 VSS.n438 5.2005
R3854 VSS.n911 VSS.n910 5.2005
R3855 VSS.n912 VSS.n911 5.2005
R3856 VSS.n909 VSS.n141 5.2005
R3857 VSS.n141 VSS.n140 5.2005
R3858 VSS.n1124 VSS.n1123 5.2005
R3859 VSS.n1125 VSS.n1124 5.2005
R3860 VSS.n143 VSS.n139 5.2005
R3861 VSS.n1126 VSS.n139 5.2005
R3862 VSS.n1129 VSS.n1128 5.2005
R3863 VSS.n1128 VSS.n1127 5.2005
R3864 VSS.n138 VSS.n133 5.2005
R3865 VSS.n133 VSS.n132 5.2005
R3866 VSS.n1137 VSS.n1136 5.2005
R3867 VSS.n1138 VSS.n1137 5.2005
R3868 VSS.n1135 VSS.n129 5.2005
R3869 VSS.n1139 VSS.n129 5.2005
R3870 VSS.n1143 VSS.n1142 5.2005
R3871 VSS.n1142 VSS.n1141 5.2005
R3872 VSS.n131 VSS.n130 5.2005
R3873 VSS.n1140 VSS.n131 5.2005
R3874 VSS.n122 VSS.n116 5.2005
R3875 VSS.n124 VSS.n122 5.2005
R3876 VSS.n620 VSS.n619 5.2005
R3877 VSS.n621 VSS.n620 5.2005
R3878 VSS.n590 VSS.n585 5.2005
R3879 VSS.n622 VSS.n585 5.2005
R3880 VSS.n626 VSS.n625 5.2005
R3881 VSS.n625 VSS.n624 5.2005
R3882 VSS.n586 VSS.n581 5.2005
R3883 VSS.n623 VSS.n586 5.2005
R3884 VSS.n632 VSS.n580 5.2005
R3885 VSS.n580 VSS.n579 5.2005
R3886 VSS.n634 VSS.n633 5.2005
R3887 VSS.n635 VSS.n634 5.2005
R3888 VSS.n646 VSS.n578 5.2005
R3889 VSS.n636 VSS.n578 5.2005
R3890 VSS.n645 VSS.n644 5.2005
R3891 VSS.n644 VSS.n643 5.2005
R3892 VSS.n652 VSS.n574 5.2005
R3893 VSS.n642 VSS.n574 5.2005
R3894 VSS.n640 VSS.n639 5.2005
R3895 VSS.n641 VSS.n640 5.2005
R3896 VSS.n656 VSS.n571 5.2005
R3897 VSS.n638 VSS.n571 5.2005
R3898 VSS.n572 VSS.n567 5.2005
R3899 VSS.n637 VSS.n567 5.2005
R3900 VSS.n663 VSS.n662 5.2005
R3901 VSS.n663 VSS.n566 5.2005
R3902 VSS.n664 VSS.n564 5.2005
R3903 VSS.n665 VSS.n664 5.2005
R3904 VSS.n670 VSS.n565 5.2005
R3905 VSS.n666 VSS.n565 5.2005
R3906 VSS.n669 VSS.n668 5.2005
R3907 VSS.n668 VSS.n667 5.2005
R3908 VSS.n676 VSS.n553 5.2005
R3909 VSS.n553 VSS.n552 5.2005
R3910 VSS.n705 VSS.n704 5.2005
R3911 VSS.n706 VSS.n705 5.2005
R3912 VSS.n730 VSS.n540 5.2005
R3913 VSS.n707 VSS.n540 5.2005
R3914 VSS.n546 VSS.n542 5.2005
R3915 VSS.n727 VSS.n542 5.2005
R3916 VSS.n726 VSS.n725 5.2005
R3917 VSS.n723 VSS.n544 5.2005
R3918 VSS.n722 VSS.n547 5.2005
R3919 VSS.n720 VSS.n719 5.2005
R3920 VSS.n718 VSS.n548 5.2005
R3921 VSS.n717 VSS.n716 5.2005
R3922 VSS.n715 VSS.n549 5.2005
R3923 VSS.n713 VSS.n712 5.2005
R3924 VSS.n711 VSS.n551 5.2005
R3925 VSS.n710 VSS.n709 5.2005
R3926 VSS.n598 VSS.n588 5.2005
R3927 VSS.n599 VSS.n597 5.2005
R3928 VSS.n601 VSS.n600 5.2005
R3929 VSS.n603 VSS.n595 5.2005
R3930 VSS.n606 VSS.n605 5.2005
R3931 VSS.n607 VSS.n594 5.2005
R3932 VSS.n609 VSS.n608 5.2005
R3933 VSS.n611 VSS.n593 5.2005
R3934 VSS.n612 VSS.n589 5.2005
R3935 VSS.n612 VSS.n592 5.2005
R3936 VSS.n615 VSS.n614 5.2005
R3937 VSS.n616 VSS.n591 5.2005
R3938 VSS.n619 VSS.n618 5.2005
R3939 VSS.n618 VSS.n617 5.2005
R3940 VSS.n590 VSS.n584 5.2005
R3941 VSS.n584 VSS.n583 5.2005
R3942 VSS.n627 VSS.n626 5.2005
R3943 VSS.n628 VSS.n627 5.2005
R3944 VSS.n582 VSS.n581 5.2005
R3945 VSS.n629 VSS.n582 5.2005
R3946 VSS.n632 VSS.n631 5.2005
R3947 VSS.n631 VSS.n630 5.2005
R3948 VSS.n633 VSS.n577 5.2005
R3949 VSS.n577 VSS.n576 5.2005
R3950 VSS.n647 VSS.n646 5.2005
R3951 VSS.n648 VSS.n647 5.2005
R3952 VSS.n645 VSS.n575 5.2005
R3953 VSS.n649 VSS.n575 5.2005
R3954 VSS.n652 VSS.n651 5.2005
R3955 VSS.n651 VSS.n650 5.2005
R3956 VSS.n639 VSS.n570 5.2005
R3957 VSS.n570 VSS.n569 5.2005
R3958 VSS.n657 VSS.n656 5.2005
R3959 VSS.n658 VSS.n657 5.2005
R3960 VSS.n572 VSS.n568 5.2005
R3961 VSS.n659 VSS.n568 5.2005
R3962 VSS.n662 VSS.n661 5.2005
R3963 VSS.n661 VSS.n660 5.2005
R3964 VSS.n564 VSS.n563 5.2005
R3965 VSS.n563 VSS.n562 5.2005
R3966 VSS.n671 VSS.n670 5.2005
R3967 VSS.n672 VSS.n671 5.2005
R3968 VSS.n669 VSS.n561 5.2005
R3969 VSS.n673 VSS.n561 5.2005
R3970 VSS.n676 VSS.n675 5.2005
R3971 VSS.n675 VSS.n674 5.2005
R3972 VSS.n704 VSS.n541 5.2005
R3973 VSS.n543 VSS.n541 5.2005
R3974 VSS.n730 VSS.n729 5.2005
R3975 VSS.n729 VSS.n728 5.2005
R3976 VSS.n555 VSS.n554 5.2005
R3977 VSS.n700 VSS.n555 5.2005
R3978 VSS.t198 VSS.n703 5.2005
R3979 VSS.n703 VSS.n702 5.2005
R3980 VSS.n732 VSS.n539 5.2005
R3981 VSS.n701 VSS.n539 5.2005
R3982 VSS.n545 VSS.n531 5.2005
R3983 VSS.n531 VSS.n530 5.2005
R3984 VSS.n739 VSS.n738 5.2005
R3985 VSS.n740 VSS.n739 5.2005
R3986 VSS.n532 VSS.n529 5.2005
R3987 VSS.n741 VSS.n529 5.2005
R3988 VSS.n746 VSS.n744 5.2005
R3989 VSS.n744 VSS.n743 5.2005
R3990 VSS.n745 VSS.n524 5.2005
R3991 VSS.n742 VSS.n524 5.2005
R3992 VSS.n756 VSS.n755 5.2005
R3993 VSS.n756 VSS.n523 5.2005
R3994 VSS.n757 VSS.n398 5.2005
R3995 VSS.n758 VSS.n757 5.2005
R3996 VSS.n522 VSS.n399 5.2005
R3997 VSS.n759 VSS.n522 5.2005
R3998 VSS.n763 VSS.n762 5.2005
R3999 VSS.n762 VSS.n761 5.2005
R4000 VSS.n986 VSS.n401 5.2005
R4001 VSS.n760 VSS.n401 5.2005
R4002 VSS.n476 VSS.n410 5.2005
R4003 VSS.n412 VSS.n410 5.2005
R4004 VSS.t213 VSS.n980 5.2005
R4005 VSS.n980 VSS.n979 5.2005
R4006 VSS.t190 VSS.n411 5.2005
R4007 VSS.n978 VSS.n411 5.2005
R4008 VSS.n973 VSS.n972 5.2005
R4009 VSS.n972 VSS.n971 5.2005
R4010 VSS.n970 VSS.n958 5.2005
R4011 VSS.n969 VSS.n968 5.2005
R4012 VSS.n967 VSS.n966 5.2005
R4013 VSS.n965 VSS.n964 5.2005
R4014 VSS.n963 VSS.n962 5.2005
R4015 VSS.n961 VSS.n960 5.2005
R4016 VSS.n959 VSS.n417 5.2005
R4017 VSS.n976 VSS.n975 5.2005
R4018 VSS.n698 VSS.n697 5.2005
R4019 VSS.n699 VSS.n698 5.2005
R4020 VSS.n684 VSS.n560 5.2005
R4021 VSS.n686 VSS.n685 5.2005
R4022 VSS.n697 VSS.n678 5.2005
R4023 VSS.n687 VSS.n678 5.2005
R4024 VSS.n689 VSS.n688 5.2005
R4025 VSS.n691 VSS.n690 5.2005
R4026 VSS.n697 VSS.n680 5.2005
R4027 VSS.n692 VSS.n680 5.2005
R4028 VSS.n693 VSS.n681 5.2005
R4029 VSS.n695 VSS.n694 5.2005
R4030 VSS.n682 VSS.n554 5.2005
R4031 VSS.n683 VSS.n682 5.2005
R4032 VSS.t198 VSS.n537 5.2005
R4033 VSS.n537 VSS.n536 5.2005
R4034 VSS.n733 VSS.n732 5.2005
R4035 VSS.n734 VSS.n733 5.2005
R4036 VSS.n545 VSS.n535 5.2005
R4037 VSS.n735 VSS.n535 5.2005
R4038 VSS.n738 VSS.n737 5.2005
R4039 VSS.n737 VSS.n736 5.2005
R4040 VSS.n532 VSS.n528 5.2005
R4041 VSS.n528 VSS.n527 5.2005
R4042 VSS.n747 VSS.n746 5.2005
R4043 VSS.n748 VSS.n747 5.2005
R4044 VSS.n745 VSS.n525 5.2005
R4045 VSS.n749 VSS.n525 5.2005
R4046 VSS.n755 VSS.n754 5.2005
R4047 VSS.n754 VSS.n753 5.2005
R4048 VSS.n526 VSS.n398 5.2005
R4049 VSS.n752 VSS.n526 5.2005
R4050 VSS.n750 VSS.n399 5.2005
R4051 VSS.n751 VSS.n750 5.2005
R4052 VSS.n763 VSS.n403 5.2005
R4053 VSS.n405 VSS.n403 5.2005
R4054 VSS.n986 VSS.n985 5.2005
R4055 VSS.n985 VSS.n984 5.2005
R4056 VSS.n476 VSS.n404 5.2005
R4057 VSS.n983 VSS.n404 5.2005
R4058 VSS.n981 VSS.t213 5.2005
R4059 VSS.n982 VSS.n981 5.2005
R4060 VSS.t190 VSS.n407 5.2005
R4061 VSS.n407 VSS.n406 5.2005
R4062 VSS.t181 VSS.n849 5.2005
R4063 VSS.n849 VSS.n848 5.2005
R4064 VSS.n803 VSS.n469 5.2005
R4065 VSS.n469 VSS.n468 5.2005
R4066 VSS.n857 VSS.n856 5.2005
R4067 VSS.n858 VSS.n857 5.2005
R4068 VSS.n887 VSS.n446 5.2005
R4069 VSS.n859 VSS.n446 5.2005
R4070 VSS.n954 VSS.n419 5.2005
R4071 VSS.n860 VSS.n419 5.2005
R4072 VSS.n881 VSS.n455 5.2005
R4073 VSS.n861 VSS.n455 5.2005
R4074 VSS.n452 VSS.n451 5.2005
R4075 VSS.n826 VSS.n824 5.2005
R4076 VSS.n829 VSS.n828 5.2005
R4077 VSS.n830 VSS.n823 5.2005
R4078 VSS.n832 VSS.n831 5.2005
R4079 VSS.n834 VSS.n822 5.2005
R4080 VSS.n838 VSS.n837 5.2005
R4081 VSS.n835 VSS.n467 5.2005
R4082 VSS.n847 VSS.n478 5.2005
R4083 VSS.n821 VSS.n820 5.2005
R4084 VSS.n818 VSS.n479 5.2005
R4085 VSS.n816 VSS.n815 5.2005
R4086 VSS.n814 VSS.n480 5.2005
R4087 VSS.n813 VSS.n812 5.2005
R4088 VSS.n810 VSS.n481 5.2005
R4089 VSS.n808 VSS.n807 5.2005
R4090 VSS.t181 VSS.n475 5.2005
R4091 VSS.n806 VSS.n475 5.2005
R4092 VSS.n804 VSS.n803 5.2005
R4093 VSS.n805 VSS.n804 5.2005
R4094 VSS.n856 VSS.n449 5.2005
R4095 VSS.n450 VSS.n449 5.2005
R4096 VSS.n887 VSS.n886 5.2005
R4097 VSS.n886 VSS.n885 5.2005
R4098 VSS.n954 VSS.n422 5.2005
R4099 VSS.n884 VSS.n422 5.2005
R4100 VSS.n882 VSS.n881 5.2005
R4101 VSS.n883 VSS.n882 5.2005
R4102 VSS.t181 VSS.n477 5.2005
R4103 VSS.n507 VSS.n477 5.2005
R4104 VSS.n803 VSS.n512 5.2005
R4105 VSS.n512 VSS.n511 5.2005
R4106 VSS.n856 VSS.n470 5.2005
R4107 VSS.n510 VSS.n470 5.2005
R4108 VSS.n887 VSS.n447 5.2005
R4109 VSS.n509 VSS.n447 5.2005
R4110 VSS.n954 VSS.n420 5.2005
R4111 VSS.n508 VSS.n420 5.2005
R4112 VSS.n881 VSS.n456 5.2005
R4113 VSS.n466 VSS.n456 5.2005
R4114 VSS.n878 VSS.n458 5.2005
R4115 VSS.n877 VSS.n876 5.2005
R4116 VSS.n875 VSS.n460 5.2005
R4117 VSS.n873 VSS.n872 5.2005
R4118 VSS.n871 VSS.n462 5.2005
R4119 VSS.n870 VSS.n869 5.2005
R4120 VSS.n868 VSS.n463 5.2005
R4121 VSS.n866 VSS.n865 5.2005
R4122 VSS.n506 VSS.n505 5.2005
R4123 VSS.n503 VSS.n502 5.2005
R4124 VSS.n501 VSS.n489 5.2005
R4125 VSS.n500 VSS.n499 5.2005
R4126 VSS.n497 VSS.n490 5.2005
R4127 VSS.n495 VSS.n494 5.2005
R4128 VSS.n493 VSS.n492 5.2005
R4129 VSS.n473 VSS.n472 5.2005
R4130 VSS.n850 VSS.t181 5.2005
R4131 VSS.n851 VSS.n850 5.2005
R4132 VSS.n803 VSS.n471 5.2005
R4133 VSS.n852 VSS.n471 5.2005
R4134 VSS.n856 VSS.n855 5.2005
R4135 VSS.n855 VSS.n854 5.2005
R4136 VSS.n887 VSS.n448 5.2005
R4137 VSS.n853 VSS.n448 5.2005
R4138 VSS.n954 VSS.n421 5.2005
R4139 VSS.n459 VSS.n421 5.2005
R4140 VSS.n881 VSS.n880 5.2005
R4141 VSS.n880 VSS.n879 5.2005
R4142 VSS.n943 VSS.n942 5.2005
R4143 VSS.n940 VSS.n434 5.2005
R4144 VSS.n998 VSS.n395 5.2005
R4145 VSS.n997 VSS.n996 5.2005
R4146 VSS.n993 VSS.n397 5.2005
R4147 VSS.n397 VSS.n396 5.2005
R4148 VSS.t171 VSS.n400 5.2005
R4149 VSS.n770 VSS.n400 5.2005
R4150 VSS.n764 VSS.t173 5.2005
R4151 VSS.n771 VSS.n764 5.2005
R4152 VSS.n775 VSS.n774 5.2005
R4153 VSS.n774 VSS.n773 5.2005
R4154 VSS.n769 VSS.n768 5.2005
R4155 VSS.n772 VSS.n769 5.2005
R4156 VSS.n856 VSS.n445 5.2005
R4157 VSS.n445 VSS.n444 5.2005
R4158 VSS.n891 VSS.n890 5.2005
R4159 VSS.n892 VSS.n891 5.2005
R4160 VSS.n881 VSS.n443 5.2005
R4161 VSS.n893 VSS.n443 5.2005
R4162 VSS.t256 VSS.n895 5.2005
R4163 VSS.n895 VSS.n894 5.2005
R4164 VSS.n441 VSS.n431 5.2005
R4165 VSS.n433 VSS.n431 5.2005
R4166 VSS.n947 VSS.n946 5.2005
R4167 VSS.n946 VSS.n945 5.2005
R4168 VSS.n435 VSS.n432 5.2005
R4169 VSS.n944 VSS.n432 5.2005
R4170 VSS.n939 VSS.n938 5.2005
R4171 VSS.n937 VSS.n936 5.2005
R4172 VSS.n935 VSS.n934 5.2005
R4173 VSS.n929 VSS.n928 5.2005
R4174 VSS.n927 VSS.n926 5.2005
R4175 VSS.n925 VSS.n924 5.2005
R4176 VSS.n923 VSS.n292 5.2005
R4177 VSS.n1110 VSS.n289 5.2005
R4178 VSS.n1008 VSS.n318 5.2005
R4179 VSS.n1008 VSS.n1005 5.2005
R4180 VSS.n1007 VSS.n290 5.2005
R4181 VSS.n1112 VSS.n1111 5.2005
R4182 VSS.n1192 VSS.n112 5.2005
R4183 VSS.n112 VSS.n111 5.2005
R4184 VSS.n1194 VSS.n1193 5.2005
R4185 VSS.n1195 VSS.n1194 5.2005
R4186 VSS.n113 VSS.n110 5.2005
R4187 VSS.n1196 VSS.n110 5.2005
R4188 VSS.n1199 VSS.n1198 5.2005
R4189 VSS.n1198 VSS.n1197 5.2005
R4190 VSS.n109 VSS.n99 5.2005
R4191 VSS.n99 VSS.n98 5.2005
R4192 VSS.n1205 VSS.t269 5.2005
R4193 VSS.n1206 VSS.n1205 5.2005
R4194 VSS.n100 VSS.n97 5.2005
R4195 VSS.n1207 VSS.n97 5.2005
R4196 VSS.n1210 VSS.n1209 5.2005
R4197 VSS.n1209 VSS.n1208 5.2005
R4198 VSS.n1214 VSS.n91 5.2005
R4199 VSS.n91 VSS.n90 5.2005
R4200 VSS.n1216 VSS.n1215 5.2005
R4201 VSS.n1217 VSS.n1216 5.2005
R4202 VSS.n93 VSS.n89 5.2005
R4203 VSS.n1218 VSS.n89 5.2005
R4204 VSS.n1221 VSS.n1220 5.2005
R4205 VSS.n1220 VSS.n1219 5.2005
R4206 VSS.n88 VSS.n78 5.2005
R4207 VSS.n78 VSS.n77 5.2005
R4208 VSS.n1227 VSS.t94 5.2005
R4209 VSS.n1228 VSS.n1227 5.2005
R4210 VSS.n79 VSS.n76 5.2005
R4211 VSS.n1229 VSS.n76 5.2005
R4212 VSS.n1232 VSS.n1231 5.2005
R4213 VSS.n1231 VSS.n1230 5.2005
R4214 VSS.n1233 VSS.n72 5.2005
R4215 VSS.n72 VSS.n71 5.2005
R4216 VSS.n1235 VSS.n1234 5.2005
R4217 VSS.n1236 VSS.n1235 5.2005
R4218 VSS.n70 VSS.n67 5.2005
R4219 VSS.n1237 VSS.n70 5.2005
R4220 VSS.n67 VSS.n63 5.2005
R4221 VSS.n63 VSS.n61 5.2005
R4222 VSS.n1234 VSS.n73 5.2005
R4223 VSS.n82 VSS.n73 5.2005
R4224 VSS.n1233 VSS.n74 5.2005
R4225 VSS.n83 VSS.n74 5.2005
R4226 VSS.n1232 VSS.n75 5.2005
R4227 VSS.n84 VSS.n75 5.2005
R4228 VSS.n80 VSS.n79 5.2005
R4229 VSS.n85 VSS.n80 5.2005
R4230 VSS.t94 VSS.n1226 5.2005
R4231 VSS.n1226 VSS.n1225 5.2005
R4232 VSS.n88 VSS.n81 5.2005
R4233 VSS.n1224 VSS.n81 5.2005
R4234 VSS.n1222 VSS.n1221 5.2005
R4235 VSS.n1223 VSS.n1222 5.2005
R4236 VSS.n93 VSS.n87 5.2005
R4237 VSS.n87 VSS.n86 5.2005
R4238 VSS.n1215 VSS.n94 5.2005
R4239 VSS.n103 VSS.n94 5.2005
R4240 VSS.n1214 VSS.n95 5.2005
R4241 VSS.n104 VSS.n95 5.2005
R4242 VSS.n1210 VSS.n96 5.2005
R4243 VSS.n105 VSS.n96 5.2005
R4244 VSS.n101 VSS.n100 5.2005
R4245 VSS.n106 VSS.n101 5.2005
R4246 VSS.t269 VSS.n1204 5.2005
R4247 VSS.n1204 VSS.n1203 5.2005
R4248 VSS.n109 VSS.n102 5.2005
R4249 VSS.n1202 VSS.n102 5.2005
R4250 VSS.n1200 VSS.n1199 5.2005
R4251 VSS.n1201 VSS.n1200 5.2005
R4252 VSS.n113 VSS.n108 5.2005
R4253 VSS.n108 VSS.n107 5.2005
R4254 VSS.n1193 VSS.n114 5.2005
R4255 VSS.n1176 VSS.n114 5.2005
R4256 VSS.n1192 VSS.n115 5.2005
R4257 VSS.n1177 VSS.n115 5.2005
R4258 VSS.n1191 VSS.n1190 5.2005
R4259 VSS.n1190 VSS.n1189 5.2005
R4260 VSS.n1188 VSS.n1175 5.2005
R4261 VSS.n1187 VSS.n1186 5.2005
R4262 VSS.n1185 VSS.n1184 5.2005
R4263 VSS.n1183 VSS.n1182 5.2005
R4264 VSS.n1181 VSS.n1180 5.2005
R4265 VSS.n1179 VSS.n1178 5.2005
R4266 VSS.n1250 VSS.n1249 5.2005
R4267 VSS.n64 VSS.n62 5.2005
R4268 VSS.n1239 VSS.n1238 5.2005
R4269 VSS.n1241 VSS.n1240 5.2005
R4270 VSS.n1247 VSS.n68 5.2005
R4271 VSS.n1242 VSS.n68 5.2005
R4272 VSS.n1243 VSS.n69 5.2005
R4273 VSS.n1245 VSS.n1244 5.2005
R4274 VSS.n430 VSS.t148 4.95782
R4275 VSS.t392 VSS.n454 4.73439
R4276 VSS.t427 VSS.n409 4.73439
R4277 VSS.n350 VSS.n349 4.7005
R4278 VSS.n123 VSS.n121 4.6486
R4279 VSS.n1164 VSS.n120 4.6486
R4280 VSS.n1160 VSS.n119 4.6486
R4281 VSS.n1156 VSS.n118 4.6486
R4282 VSS.n1152 VSS.n117 4.6486
R4283 VSS.n797 VSS.n796 4.6486
R4284 VSS.n782 VSS.n516 4.6486
R4285 VSS.n783 VSS.n518 4.6486
R4286 VSS.n787 VSS.n519 4.6486
R4287 VSS.n725 VSS.n724 4.6486
R4288 VSS.n722 VSS.n721 4.6486
R4289 VSS.n550 VSS.n548 4.6486
R4290 VSS.n715 VSS.n714 4.6486
R4291 VSS.n708 VSS.n551 4.6486
R4292 VSS.n597 VSS.n596 4.6486
R4293 VSS.n603 VSS.n602 4.6486
R4294 VSS.n605 VSS.n604 4.6486
R4295 VSS.n611 VSS.n610 4.6486
R4296 VSS.n1175 VSS.n1174 4.6486
R4297 VSS.n1185 VSS.n1173 4.6486
R4298 VSS.n1181 VSS.n1172 4.6486
R4299 VSS.n1249 VSS.n1248 4.6486
R4300 VSS.n1238 VSS.n66 4.6486
R4301 VSS.n1248 VSS.n64 4.6486
R4302 VSS.n1240 VSS.n66 4.6486
R4303 VSS.n1178 VSS.n1172 4.6486
R4304 VSS.n1182 VSS.n1173 4.6486
R4305 VSS.n1186 VSS.n1174 4.6486
R4306 VSS.n596 VSS.n588 4.6486
R4307 VSS.n602 VSS.n601 4.6486
R4308 VSS.n604 VSS.n594 4.6486
R4309 VSS.n610 VSS.n609 4.6486
R4310 VSS.n709 VSS.n708 4.6486
R4311 VSS.n714 VSS.n713 4.6486
R4312 VSS.n716 VSS.n550 4.6486
R4313 VSS.n721 VSS.n720 4.6486
R4314 VSS.n724 VSS.n723 4.6486
R4315 VSS.n796 VSS.n515 4.6486
R4316 VSS.n779 VSS.n516 4.6486
R4317 VSS.n786 VSS.n518 4.6486
R4318 VSS.n789 VSS.n519 4.6486
R4319 VSS.n1149 VSS.n117 4.6486
R4320 VSS.n1153 VSS.n118 4.6486
R4321 VSS.n1157 VSS.n119 4.6486
R4322 VSS.n1161 VSS.n120 4.6486
R4323 VSS.n1165 VSS.n121 4.6486
R4324 VSS.n251 VSS.n249 4.59524
R4325 VSS.n1116 VSS.n1115 4.5005
R4326 VSS.n1115 VSS.n288 4.5005
R4327 VSS.n1116 VSS.n284 4.5005
R4328 VSS.n285 VSS.n284 4.5005
R4329 VSS.n843 VSS.n840 4.5005
R4330 VSS.n845 VSS.n844 4.5005
R4331 VSS.n485 VSS.n482 4.5005
R4332 VSS.n487 VSS.n486 4.5005
R4333 VSS.n286 VSS.n285 4.5005
R4334 VSS.n288 VSS.n286 4.5005
R4335 VSS.n1120 VSS.n1119 4.5005
R4336 VSS.n176 VSS.n175 4.5005
R4337 VSS.n174 VSS.n173 4.5005
R4338 VSS.n573 VSS.n59 4.5005
R4339 VSS.n33 VSS.n28 4.5005
R4340 VSS.n27 VSS.n26 4.5005
R4341 VSS.n225 VSS.n224 4.5005
R4342 VSS.n239 VSS.n238 4.5005
R4343 VSS.n210 VSS.n209 4.5005
R4344 VSS.n268 VSS.n267 4.5005
R4345 VSS.n257 VSS.n256 4.5005
R4346 VSS.n278 VSS.n277 4.5005
R4347 VSS.n1121 VSS.n1120 4.49787
R4348 VSS.n654 VSS.n573 4.49787
R4349 VSS.n379 VSS.n378 4.48215
R4350 VSS.n339 VSS.n335 4.48215
R4351 VSS.n388 VSS.n387 4.48215
R4352 VSS.n1050 VSS.n1049 4.48215
R4353 VSS.n1046 VSS.n326 4.48215
R4354 VSS.n368 VSS.n367 4.34122
R4355 VSS.n365 VSS.n364 4.34122
R4356 VSS.n330 VSS.n324 4.34122
R4357 VSS.n1059 VSS.n321 4.34122
R4358 VSS.n1065 VSS.n319 4.34122
R4359 VSS.n364 VSS.n363 4.34122
R4360 VSS.n367 VSS.n366 4.34122
R4361 VSS.n1065 VSS.n1064 4.34122
R4362 VSS.n1060 VSS.n1059 4.34122
R4363 VSS.n328 VSS.n324 4.34122
R4364 VSS.n1022 VSS.n1021 4.34122
R4365 VSS.n1003 VSS.n1001 4.34122
R4366 VSS.n1015 VSS.n1014 4.34122
R4367 VSS.n1006 VSS.n1004 4.34122
R4368 VSS.n1024 VSS.n391 4.34122
R4369 VSS.n1033 VSS.n392 4.34122
R4370 VSS.n1037 VSS.n393 4.34122
R4371 VSS.n1044 VSS.n394 4.34122
R4372 VSS.n958 VSS.n957 4.34122
R4373 VSS.n967 VSS.n956 4.34122
R4374 VSS.n963 VSS.n955 4.34122
R4375 VSS.n974 VSS.n417 4.34122
R4376 VSS.n685 VSS.n679 4.34122
R4377 VSS.n688 VSS.n677 4.34122
R4378 VSS.n696 VSS.n681 4.34122
R4379 VSS.n825 VSS.n452 4.34122
R4380 VSS.n828 VSS.n827 4.34122
R4381 VSS.n833 VSS.n832 4.34122
R4382 VSS.n837 VSS.n836 4.34122
R4383 VSS.n819 VSS.n478 4.34122
R4384 VSS.n817 VSS.n816 4.34122
R4385 VSS.n812 VSS.n811 4.34122
R4386 VSS.n810 VSS.n809 4.34122
R4387 VSS.n461 VSS.n458 4.34122
R4388 VSS.n875 VSS.n874 4.34122
R4389 VSS.n464 VSS.n462 4.34122
R4390 VSS.n868 VSS.n867 4.34122
R4391 VSS.n505 VSS.n504 4.34122
R4392 VSS.n498 VSS.n489 4.34122
R4393 VSS.n497 VSS.n496 4.34122
R4394 VSS.n492 VSS.n491 4.34122
R4395 VSS.n942 VSS.n941 4.34122
R4396 VSS.n995 VSS.n395 4.34122
R4397 VSS.n939 VSS.n294 4.34122
R4398 VSS.n935 VSS.n295 4.34122
R4399 VSS.n927 VSS.n296 4.34122
R4400 VSS.n1109 VSS.n292 4.34122
R4401 VSS.n1007 VSS.n291 4.34122
R4402 VSS.n1111 VSS.n291 4.34122
R4403 VSS.n1009 VSS.n1006 4.34122
R4404 VSS.n1014 VSS.n1013 4.34122
R4405 VSS.n1016 VSS.n1003 4.34122
R4406 VSS.n1021 VSS.n1020 4.34122
R4407 VSS.n1110 VSS.n1109 4.34122
R4408 VSS.n924 VSS.n296 4.34122
R4409 VSS.n928 VSS.n295 4.34122
R4410 VSS.n936 VSS.n294 4.34122
R4411 VSS.n941 VSS.n940 4.34122
R4412 VSS.n1032 VSS.n391 4.34122
R4413 VSS.n1036 VSS.n392 4.34122
R4414 VSS.n1039 VSS.n393 4.34122
R4415 VSS.n1044 VSS.n1043 4.34122
R4416 VSS.n996 VSS.n995 4.34122
R4417 VSS.n504 VSS.n503 4.34122
R4418 VSS.n499 VSS.n498 4.34122
R4419 VSS.n496 VSS.n495 4.34122
R4420 VSS.n491 VSS.n473 4.34122
R4421 VSS.n867 VSS.n866 4.34122
R4422 VSS.n869 VSS.n464 4.34122
R4423 VSS.n874 VSS.n873 4.34122
R4424 VSS.n876 VSS.n461 4.34122
R4425 VSS.n820 VSS.n819 4.34122
R4426 VSS.n818 VSS.n817 4.34122
R4427 VSS.n811 VSS.n480 4.34122
R4428 VSS.n809 VSS.n808 4.34122
R4429 VSS.n836 VSS.n835 4.34122
R4430 VSS.n834 VSS.n833 4.34122
R4431 VSS.n827 VSS.n823 4.34122
R4432 VSS.n826 VSS.n825 4.34122
R4433 VSS.n679 VSS.n560 4.34122
R4434 VSS.n690 VSS.n677 4.34122
R4435 VSS.n696 VSS.n695 4.34122
R4436 VSS.n975 VSS.n974 4.34122
R4437 VSS.n960 VSS.n955 4.34122
R4438 VSS.n964 VSS.n956 4.34122
R4439 VSS.n968 VSS.n957 4.34122
R4440 VSS.n1246 VSS.n69 4.20229
R4441 VSS.n1246 VSS.n1245 4.20229
R4442 VSS.n992 VSS.n991 4.08867
R4443 VSS.n802 VSS.n409 4.08867
R4444 VSS.n454 VSS.n453 4.08867
R4445 VSS.n163 VSS.n159 3.83734
R4446 VSS.n19 VSS.n15 3.83734
R4447 VSS.n794 VSS.n520 3.72542
R4448 VSS.n614 VSS.n613 3.72542
R4449 VSS.n613 VSS.n591 3.72542
R4450 VSS.n794 VSS.n793 3.72542
R4451 VSS.n352 VSS.n340 3.6553
R4452 VSS.n376 VSS.n375 3.6553
R4453 VSS.n1129 VSS.t179 3.64196
R4454 VSS.n1129 VSS.t434 3.64196
R4455 VSS.n916 VSS.t497 3.64196
R4456 VSS.t16 VSS.n916 3.64196
R4457 VSS.t190 VSS.t133 3.64196
R4458 VSS.t134 VSS.t190 3.64196
R4459 VSS.t132 VSS.t209 3.64196
R4460 VSS.n803 VSS.t135 3.64196
R4461 VSS.t191 VSS.t252 3.64196
R4462 VSS.n775 VSS.t495 3.64196
R4463 VSS.n986 VSS.n402 3.64196
R4464 VSS.n993 VSS.t64 3.64196
R4465 VSS.t65 VSS.n993 3.64196
R4466 VSS.n994 VSS.n398 3.64196
R4467 VSS.n730 VSS.t121 3.64196
R4468 VSS.t122 VSS.n730 3.64196
R4469 VSS.n662 VSS.t163 3.64196
R4470 VSS.n662 VSS.t114 3.64196
R4471 VSS.n646 VSS.t302 3.64196
R4472 VSS.n646 VSS.t418 3.64196
R4473 VSS.n988 VSS.n987 3.63551
R4474 VSS.n521 VSS.n474 3.63551
R4475 VSS.n948 VSS.n428 3.56721
R4476 VSS.n441 VSS.n428 3.56721
R4477 VSS.n731 VSS.n538 3.54389
R4478 VSS.n534 VSS.n533 3.54389
R4479 VSS.n990 VSS.n989 3.54389
R4480 VSS.n766 VSS.n765 3.54389
R4481 VSS.n767 VSS.t136 3.45988
R4482 VSS.n164 VSS.n163 3.43471
R4483 VSS.n20 VSS.n19 3.43471
R4484 VSS.n350 VSS.n0 3.2405
R4485 VSS.t64 VSS.n992 2.91367
R4486 VSS.n1117 VSS.n1116 2.80513
R4487 VSS.n175 VSS.n174 2.73963
R4488 VSS.n28 VSS.n27 2.73963
R4489 VSS.n1117 VSS.n0 2.633
R4490 VSS.n454 VSS.t390 2.54952
R4491 VSS.t213 VSS.n409 2.54952
R4492 VSS.n802 VSS.t132 2.54952
R4493 VSS.n991 VSS.n399 2.54952
R4494 VSS.n1116 VSS.n286 2.29365
R4495 VSS.n889 VSS.t326 2.0033
R4496 VSS.t213 VSS.n408 2.0033
R4497 VSS.t503 VSS.n767 2.0033
R4498 VSS.n768 VSS.n766 2.0033
R4499 VSS.t181 VSS.n474 2.0033
R4500 VSS.n765 VSS.t191 2.0033
R4501 VSS.n775 VSS.n521 2.0033
R4502 VSS.n989 VSS.t149 2.0033
R4503 VSS.n130 VSS.t202 1.82123
R4504 VSS.n1143 VSS.t406 1.82123
R4505 VSS.t164 VSS.t479 1.82123
R4506 VSS.t56 VSS.t477 1.82123
R4507 VSS.n143 VSS.t323 1.82123
R4508 VSS.n902 VSS.t487 1.82123
R4509 VSS.t474 VSS.t328 1.82123
R4510 VSS.t170 VSS.t300 1.82123
R4511 VSS.n881 VSS.t392 1.82123
R4512 VSS.t20 VSS.t344 1.82123
R4513 VSS.t338 VSS.n954 1.82123
R4514 VSS.n973 VSS.t338 1.82123
R4515 VSS.n890 VSS.t324 1.82123
R4516 VSS.n856 VSS.t427 1.82123
R4517 VSS.t23 VSS.t211 1.82123
R4518 VSS.t135 VSS.t62 1.82123
R4519 VSS.n803 VSS.t505 1.82123
R4520 VSS.t136 VSS.t505 1.82123
R4521 VSS.t495 VSS.n402 1.82123
R4522 VSS.n795 VSS.t452 1.82123
R4523 VSS.n546 VSS.t444 1.82123
R4524 VSS.t292 VSS.t66 1.82123
R4525 VSS.t290 VSS.t67 1.82123
R4526 VSS.n704 VSS.t286 1.82123
R4527 VSS.n697 VSS.t374 1.82123
R4528 VSS.t374 VSS.n676 1.82123
R4529 VSS.t420 VSS.t348 1.82123
R4530 VSS.t467 VSS.t346 1.82123
R4531 VSS.n572 VSS.t180 1.82123
R4532 VSS.t500 VSS.n645 1.82123
R4533 VSS.t468 VSS.t146 1.82123
R4534 VSS.t167 VSS.t417 1.82123
R4535 VSS.n626 VSS.t398 1.82123
R4536 VSS.n590 VSS.t360 1.82123
R4537 VSS.n767 VSS.n408 1.75086
R4538 VSS.n889 VSS.n888 1.75086
R4539 VSS.n765 VSS.t251 1.63916
R4540 VSS.t494 VSS.n521 1.63916
R4541 VSS.n987 VSS.t452 1.63916
R4542 VSS.n988 VSS.t141 1.63916
R4543 VSS.t439 VSS.n990 1.63916
R4544 VSS.n534 VSS.t440 1.63916
R4545 VSS.t254 VSS.n731 1.63916
R4546 VSS.n186 VSS.n182 1.3505
R4547 VSS.n42 VSS.n38 1.3505
R4548 VSS.n202 VSS.n196 1.23208
R4549 VSS.n182 VSS.n179 1.23208
R4550 VSS.n38 VSS.n35 1.23208
R4551 VSS.n58 VSS.n52 1.23208
R4552 VSS.n1147 VSS.n1146 1.1255
R4553 VSS.n1146 VSS.n1145 1.1255
R4554 VSS.n1145 VSS.n127 1.1255
R4555 VSS.n1133 VSS.n127 1.1255
R4556 VSS.n1133 VSS.n1132 1.1255
R4557 VSS.n1132 VSS.n1131 1.1255
R4558 VSS.n1131 VSS.n136 1.1255
R4559 VSS.n906 VSS.n136 1.1255
R4560 VSS.n907 VSS.n906 1.1255
R4561 VSS.n907 VSS.n905 1.1255
R4562 VSS.n905 VSS.n904 1.1255
R4563 VSS.n904 VSS.n901 1.1255
R4564 VSS.n901 VSS.n900 1.1255
R4565 VSS.n900 VSS.n898 1.1255
R4566 VSS.n898 VSS.n897 1.1255
R4567 VSS.n897 VSS.n440 1.1255
R4568 VSS.n800 VSS.n440 1.1255
R4569 VSS.n800 VSS.n799 1.1255
R4570 VSS.n798 VSS.n514 1.1255
R4571 VSS.n778 VSS.n514 1.1255
R4572 VSS.n780 VSS.n778 1.1255
R4573 VSS.n781 VSS.n780 1.1255
R4574 VSS.n784 VSS.n781 1.1255
R4575 VSS.n785 VSS.n784 1.1255
R4576 VSS.n788 VSS.n785 1.1255
R4577 VSS.n790 VSS.n788 1.1255
R4578 VSS.n791 VSS.n790 1.1255
R4579 VSS.n1140 VSS.n124 1.1255
R4580 VSS.n1141 VSS.n1140 1.1255
R4581 VSS.n1141 VSS.n1139 1.1255
R4582 VSS.n1139 VSS.n1138 1.1255
R4583 VSS.n1138 VSS.n132 1.1255
R4584 VSS.n1127 VSS.n132 1.1255
R4585 VSS.n1127 VSS.n1126 1.1255
R4586 VSS.n1126 VSS.n1125 1.1255
R4587 VSS.n1125 VSS.n140 1.1255
R4588 VSS.n912 VSS.n140 1.1255
R4589 VSS.n913 VSS.n912 1.1255
R4590 VSS.n914 VSS.n913 1.1255
R4591 VSS.n914 VSS.n426 1.1255
R4592 VSS.n950 VSS.n426 1.1255
R4593 VSS.n951 VSS.n950 1.1255
R4594 VSS.n952 VSS.n951 1.1255
R4595 VSS.n952 VSS.n425 1.1255
R4596 VSS.n777 VSS.n425 1.1255
R4597 VSS.n1151 VSS.n1150 1.1255
R4598 VSS.n1154 VSS.n1151 1.1255
R4599 VSS.n1155 VSS.n1154 1.1255
R4600 VSS.n1158 VSS.n1155 1.1255
R4601 VSS.n1159 VSS.n1158 1.1255
R4602 VSS.n1162 VSS.n1159 1.1255
R4603 VSS.n1163 VSS.n1162 1.1255
R4604 VSS.n1166 VSS.n1163 1.1255
R4605 VSS.n1167 VSS.n1166 1.1255
R4606 VSS.n707 VSS.n706 1.1255
R4607 VSS.n706 VSS.n552 1.1255
R4608 VSS.n667 VSS.n552 1.1255
R4609 VSS.n667 VSS.n666 1.1255
R4610 VSS.n666 VSS.n665 1.1255
R4611 VSS.n665 VSS.n566 1.1255
R4612 VSS.n637 VSS.n566 1.1255
R4613 VSS.n638 VSS.n637 1.1255
R4614 VSS.n641 VSS.n638 1.1255
R4615 VSS.n642 VSS.n641 1.1255
R4616 VSS.n643 VSS.n642 1.1255
R4617 VSS.n643 VSS.n636 1.1255
R4618 VSS.n636 VSS.n635 1.1255
R4619 VSS.n635 VSS.n579 1.1255
R4620 VSS.n623 VSS.n579 1.1255
R4621 VSS.n624 VSS.n623 1.1255
R4622 VSS.n624 VSS.n622 1.1255
R4623 VSS.n622 VSS.n621 1.1255
R4624 VSS.n711 VSS.n710 1.1255
R4625 VSS.n712 VSS.n711 1.1255
R4626 VSS.n712 VSS.n549 1.1255
R4627 VSS.n717 VSS.n549 1.1255
R4628 VSS.n718 VSS.n717 1.1255
R4629 VSS.n719 VSS.n718 1.1255
R4630 VSS.n719 VSS.n547 1.1255
R4631 VSS.n547 VSS.n544 1.1255
R4632 VSS.n726 VSS.n544 1.1255
R4633 VSS.n728 VSS.n543 1.1255
R4634 VSS.n674 VSS.n543 1.1255
R4635 VSS.n674 VSS.n673 1.1255
R4636 VSS.n673 VSS.n672 1.1255
R4637 VSS.n672 VSS.n562 1.1255
R4638 VSS.n660 VSS.n562 1.1255
R4639 VSS.n660 VSS.n659 1.1255
R4640 VSS.n659 VSS.n658 1.1255
R4641 VSS.n658 VSS.n569 1.1255
R4642 VSS.n650 VSS.n569 1.1255
R4643 VSS.n650 VSS.n649 1.1255
R4644 VSS.n649 VSS.n648 1.1255
R4645 VSS.n648 VSS.n576 1.1255
R4646 VSS.n630 VSS.n576 1.1255
R4647 VSS.n630 VSS.n629 1.1255
R4648 VSS.n629 VSS.n628 1.1255
R4649 VSS.n628 VSS.n583 1.1255
R4650 VSS.n617 VSS.n583 1.1255
R4651 VSS.n599 VSS.n598 1.1255
R4652 VSS.n600 VSS.n599 1.1255
R4653 VSS.n600 VSS.n595 1.1255
R4654 VSS.n606 VSS.n595 1.1255
R4655 VSS.n607 VSS.n606 1.1255
R4656 VSS.n608 VSS.n607 1.1255
R4657 VSS.n608 VSS.n593 1.1255
R4658 VSS.n593 VSS.n592 1.1255
R4659 VSS.n615 VSS.n592 1.1255
R4660 VSS.n1250 VSS.n62 1.1255
R4661 VSS.n1239 VSS.n62 1.1255
R4662 VSS.n1241 VSS.n1239 1.1255
R4663 VSS.n1242 VSS.n1241 1.1255
R4664 VSS.n1243 VSS.n1242 1.1255
R4665 VSS.n1177 VSS.n1176 1.1255
R4666 VSS.n1176 VSS.n107 1.1255
R4667 VSS.n1201 VSS.n107 1.1255
R4668 VSS.n1202 VSS.n1201 1.1255
R4669 VSS.n1203 VSS.n1202 1.1255
R4670 VSS.n1203 VSS.n106 1.1255
R4671 VSS.n106 VSS.n105 1.1255
R4672 VSS.n105 VSS.n104 1.1255
R4673 VSS.n104 VSS.n103 1.1255
R4674 VSS.n103 VSS.n86 1.1255
R4675 VSS.n1223 VSS.n86 1.1255
R4676 VSS.n1224 VSS.n1223 1.1255
R4677 VSS.n1225 VSS.n1224 1.1255
R4678 VSS.n1225 VSS.n85 1.1255
R4679 VSS.n85 VSS.n84 1.1255
R4680 VSS.n84 VSS.n83 1.1255
R4681 VSS.n83 VSS.n82 1.1255
R4682 VSS.n82 VSS.n61 1.1255
R4683 VSS.n1180 VSS.n1179 1.1255
R4684 VSS.n1183 VSS.n1180 1.1255
R4685 VSS.n1184 VSS.n1183 1.1255
R4686 VSS.n1187 VSS.n1184 1.1255
R4687 VSS.n1188 VSS.n1187 1.1255
R4688 VSS.n1195 VSS.n111 1.1255
R4689 VSS.n1196 VSS.n1195 1.1255
R4690 VSS.n1197 VSS.n1196 1.1255
R4691 VSS.n1197 VSS.n98 1.1255
R4692 VSS.n1206 VSS.n98 1.1255
R4693 VSS.n1207 VSS.n1206 1.1255
R4694 VSS.n1208 VSS.n1207 1.1255
R4695 VSS.n1208 VSS.n90 1.1255
R4696 VSS.n1217 VSS.n90 1.1255
R4697 VSS.n1218 VSS.n1217 1.1255
R4698 VSS.n1219 VSS.n1218 1.1255
R4699 VSS.n1219 VSS.n77 1.1255
R4700 VSS.n1228 VSS.n77 1.1255
R4701 VSS.n1229 VSS.n1228 1.1255
R4702 VSS.n1230 VSS.n1229 1.1255
R4703 VSS.n1230 VSS.n71 1.1255
R4704 VSS.n1236 VSS.n71 1.1255
R4705 VSS.n1237 VSS.n1236 1.1255
R4706 VSS.n453 VSS.t340 1.09294
R4707 VSS.t62 VSS.n802 1.09294
R4708 VSS.n1115 VSS.n287 0.992495
R4709 VSS.n863 VSS.n287 0.991003
R4710 VSS.n1103 VSS.n301 0.9905
R4711 VSS.n639 VSS.n390 0.910864
R4712 VSS.n349 VSS.n348 0.9005
R4713 VSS.n348 VSS.n347 0.9005
R4714 VSS.n347 VSS.n346 0.9005
R4715 VSS.n346 VSS.n345 0.9005
R4716 VSS.n345 VSS.n344 0.9005
R4717 VSS.n332 VSS.n331 0.878
R4718 VSS.n799 VSS.n798 0.878
R4719 VSS.n710 VSS.n707 0.878
R4720 VSS.n1179 VSS.n1177 0.878
R4721 VSS.n930 VSS.t77 0.8195
R4722 VSS.n930 VSS.t78 0.8195
R4723 VSS.n931 VSS.t69 0.8195
R4724 VSS.n931 VSS.t70 0.8195
R4725 VSS.n1076 VSS.n1075 0.7655
R4726 VSS.n997 VSS.n396 0.7655
R4727 VSS.n944 VSS.n943 0.7655
R4728 VSS.n848 VSS.n847 0.7655
R4729 VSS.n507 VSS.n506 0.7655
R4730 VSS.n795 VSS.n794 0.73879
R4731 VSS.n613 VSS.n589 0.73879
R4732 VSS.n1253 VSS.n59 0.698
R4733 VSS.n1075 VSS.n1074 0.6755
R4734 VSS.n1074 VSS.n315 0.6755
R4735 VSS.n358 VSS.n315 0.6755
R4736 VSS.n360 VSS.n358 0.6755
R4737 VSS.n361 VSS.n360 0.6755
R4738 VSS.n362 VSS.n361 0.6755
R4739 VSS.n362 VSS.n355 0.6755
R4740 VSS.n355 VSS.n351 0.6755
R4741 VSS.n369 VSS.n351 0.6755
R4742 VSS.n1076 VSS.n311 0.6755
R4743 VSS.n1082 VSS.n311 0.6755
R4744 VSS.n1083 VSS.n1082 0.6755
R4745 VSS.n1084 VSS.n1083 0.6755
R4746 VSS.n1084 VSS.n307 0.6755
R4747 VSS.n1090 VSS.n307 0.6755
R4748 VSS.n1091 VSS.n1090 0.6755
R4749 VSS.n1092 VSS.n1091 0.6755
R4750 VSS.n1092 VSS.n306 0.6755
R4751 VSS.n306 VSS.n303 0.6755
R4752 VSS.n303 VSS.n301 0.6755
R4753 VSS.n1104 VSS.n1103 0.6755
R4754 VSS.n1105 VSS.n1104 0.6755
R4755 VSS.n1105 VSS.n300 0.6755
R4756 VSS.n1063 VSS.n300 0.6755
R4757 VSS.n1063 VSS.n1062 0.6755
R4758 VSS.n1062 VSS.n1061 0.6755
R4759 VSS.n1061 VSS.n320 0.6755
R4760 VSS.n329 VSS.n320 0.6755
R4761 VSS.n331 VSS.n329 0.6755
R4762 VSS.n372 VSS.n371 0.6755
R4763 VSS.n372 VSS.n343 0.6755
R4764 VSS.n343 VSS.n337 0.6755
R4765 VSS.n382 VSS.n337 0.6755
R4766 VSS.n383 VSS.n382 0.6755
R4767 VSS.n384 VSS.n383 0.6755
R4768 VSS.n384 VSS.n333 0.6755
R4769 VSS.n1052 VSS.n333 0.6755
R4770 VSS.n1053 VSS.n1052 0.6755
R4771 VSS.n1054 VSS.n1053 0.6755
R4772 VSS.n1054 VSS.n332 0.6755
R4773 VSS.n1112 VSS.n290 0.6755
R4774 VSS.n1005 VSS.n290 0.6755
R4775 VSS.n1010 VSS.n1005 0.6755
R4776 VSS.n1011 VSS.n1010 0.6755
R4777 VSS.n1012 VSS.n1011 0.6755
R4778 VSS.n1012 VSS.n1002 0.6755
R4779 VSS.n1017 VSS.n1002 0.6755
R4780 VSS.n1018 VSS.n1017 0.6755
R4781 VSS.n1019 VSS.n1018 0.6755
R4782 VSS.n1019 VSS.n1000 0.6755
R4783 VSS.n1034 VSS.n1031 0.6755
R4784 VSS.n1035 VSS.n1034 0.6755
R4785 VSS.n1038 VSS.n1035 0.6755
R4786 VSS.n1040 VSS.n1038 0.6755
R4787 VSS.n1041 VSS.n1040 0.6755
R4788 VSS.n1042 VSS.n1041 0.6755
R4789 VSS.n1042 VSS.n998 0.6755
R4790 VSS.n998 VSS.n997 0.6755
R4791 VSS.n945 VSS.n944 0.6755
R4792 VSS.n945 VSS.n433 0.6755
R4793 VSS.n894 VSS.n433 0.6755
R4794 VSS.n894 VSS.n893 0.6755
R4795 VSS.n893 VSS.n892 0.6755
R4796 VSS.n892 VSS.n444 0.6755
R4797 VSS.n772 VSS.n444 0.6755
R4798 VSS.n773 VSS.n772 0.6755
R4799 VSS.n773 VSS.n771 0.6755
R4800 VSS.n771 VSS.n770 0.6755
R4801 VSS.n925 VSS.n923 0.6755
R4802 VSS.n926 VSS.n925 0.6755
R4803 VSS.n929 VSS.n926 0.6755
R4804 VSS.n937 VSS.n934 0.6755
R4805 VSS.n938 VSS.n937 0.6755
R4806 VSS.n938 VSS.n434 0.6755
R4807 VSS.n943 VSS.n434 0.6755
R4808 VSS.n838 VSS.n822 0.6755
R4809 VSS.n831 VSS.n822 0.6755
R4810 VSS.n831 VSS.n830 0.6755
R4811 VSS.n830 VSS.n829 0.6755
R4812 VSS.n829 VSS.n824 0.6755
R4813 VSS.n824 VSS.n451 0.6755
R4814 VSS.n821 VSS.n479 0.6755
R4815 VSS.n815 VSS.n479 0.6755
R4816 VSS.n815 VSS.n814 0.6755
R4817 VSS.n814 VSS.n813 0.6755
R4818 VSS.n813 VSS.n481 0.6755
R4819 VSS.n807 VSS.n481 0.6755
R4820 VSS.n870 VSS.n463 0.6755
R4821 VSS.n871 VSS.n870 0.6755
R4822 VSS.n872 VSS.n871 0.6755
R4823 VSS.n872 VSS.n460 0.6755
R4824 VSS.n877 VSS.n460 0.6755
R4825 VSS.n878 VSS.n877 0.6755
R4826 VSS.n502 VSS.n501 0.6755
R4827 VSS.n501 VSS.n500 0.6755
R4828 VSS.n500 VSS.n490 0.6755
R4829 VSS.n494 VSS.n490 0.6755
R4830 VSS.n494 VSS.n493 0.6755
R4831 VSS.n493 VSS.n472 0.6755
R4832 VSS.n961 VSS.n959 0.6755
R4833 VSS.n962 VSS.n961 0.6755
R4834 VSS.n965 VSS.n962 0.6755
R4835 VSS.n966 VSS.n965 0.6755
R4836 VSS.n969 VSS.n966 0.6755
R4837 VSS.n970 VSS.n969 0.6755
R4838 VSS.n971 VSS.n970 0.6755
R4839 VSS.n982 VSS.n406 0.6755
R4840 VSS.n983 VSS.n982 0.6755
R4841 VSS.n984 VSS.n983 0.6755
R4842 VSS.n984 VSS.n405 0.6755
R4843 VSS.n751 VSS.n405 0.6755
R4844 VSS.n752 VSS.n751 0.6755
R4845 VSS.n753 VSS.n752 0.6755
R4846 VSS.n753 VSS.n749 0.6755
R4847 VSS.n749 VSS.n748 0.6755
R4848 VSS.n748 VSS.n527 0.6755
R4849 VSS.n736 VSS.n527 0.6755
R4850 VSS.n736 VSS.n735 0.6755
R4851 VSS.n735 VSS.n734 0.6755
R4852 VSS.n734 VSS.n536 0.6755
R4853 VSS.n683 VSS.n536 0.6755
R4854 VSS.n686 VSS.n684 0.6755
R4855 VSS.n687 VSS.n686 0.6755
R4856 VSS.n689 VSS.n687 0.6755
R4857 VSS.n691 VSS.n689 0.6755
R4858 VSS.n692 VSS.n691 0.6755
R4859 VSS.n693 VSS.n692 0.6755
R4860 VSS.n694 VSS.n693 0.6755
R4861 VSS.n979 VSS.n978 0.6755
R4862 VSS.n979 VSS.n412 0.6755
R4863 VSS.n760 VSS.n412 0.6755
R4864 VSS.n761 VSS.n760 0.6755
R4865 VSS.n761 VSS.n759 0.6755
R4866 VSS.n759 VSS.n758 0.6755
R4867 VSS.n758 VSS.n523 0.6755
R4868 VSS.n742 VSS.n523 0.6755
R4869 VSS.n743 VSS.n742 0.6755
R4870 VSS.n743 VSS.n741 0.6755
R4871 VSS.n741 VSS.n740 0.6755
R4872 VSS.n740 VSS.n530 0.6755
R4873 VSS.n701 VSS.n530 0.6755
R4874 VSS.n702 VSS.n701 0.6755
R4875 VSS.n702 VSS.n700 0.6755
R4876 VSS.n1025 VSS.n999 0.653
R4877 VSS.n700 VSS.n699 0.653
R4878 VSS.n792 VSS.n777 0.653
R4879 VSS.n1168 VSS.n124 0.653
R4880 VSS.n728 VSS.n727 0.653
R4881 VSS.n617 VSS.n616 0.653
R4882 VSS.n1189 VSS.n111 0.653
R4883 VSS.n1244 VSS.n1237 0.653
R4884 VSS.n1119 VSS.n1118 0.6305
R4885 VSS.n959 VSS.n416 0.563
R4886 VSS.n684 VSS.n559 0.563
R4887 VSS.n1244 VSS.n1243 0.563
R4888 VSS.n1189 VSS.n1188 0.563
R4889 VSS.n807 VSS.n806 0.5405
R4890 VSS.n851 VSS.n472 0.5405
R4891 VSS.n971 VSS.n406 0.5405
R4892 VSS.n694 VSS.n683 0.5405
R4893 VSS.n244 VSS.n242 0.5405
R4894 VSS.n1147 VSS.n125 0.518
R4895 VSS.n621 VSS.n587 0.518
R4896 VSS.n1251 VSS.n61 0.518
R4897 VSS.n1247 VSS.n1246 0.500354
R4898 VSS.n370 VSS.n369 0.47417
R4899 VSS.n1000 VSS.n999 0.4505
R4900 VSS.n1031 VSS.n1030 0.4505
R4901 VSS.n770 VSS.n396 0.4505
R4902 VSS.n923 VSS.n922 0.4505
R4903 VSS.n884 VSS.n883 0.4505
R4904 VSS.n885 VSS.n884 0.4505
R4905 VSS.n885 VSS.n450 0.4505
R4906 VSS.n805 VSS.n450 0.4505
R4907 VSS.n806 VSS.n805 0.4505
R4908 VSS.n861 VSS.n860 0.4505
R4909 VSS.n860 VSS.n859 0.4505
R4910 VSS.n859 VSS.n858 0.4505
R4911 VSS.n858 VSS.n468 0.4505
R4912 VSS.n848 VSS.n468 0.4505
R4913 VSS.n879 VSS.n459 0.4505
R4914 VSS.n853 VSS.n459 0.4505
R4915 VSS.n854 VSS.n853 0.4505
R4916 VSS.n854 VSS.n852 0.4505
R4917 VSS.n852 VSS.n851 0.4505
R4918 VSS.n508 VSS.n466 0.4505
R4919 VSS.n509 VSS.n508 0.4505
R4920 VSS.n510 VSS.n509 0.4505
R4921 VSS.n511 VSS.n510 0.4505
R4922 VSS.n511 VSS.n507 0.4505
R4923 VSS.n367 VSS.n354 0.430889
R4924 VSS.n364 VSS.n354 0.430889
R4925 VSS.n1058 VSS.n324 0.430889
R4926 VSS.n1059 VSS.n1058 0.430889
R4927 VSS.n1066 VSS.n1065 0.430889
R4928 VSS.n1021 VSS.n323 0.430889
R4929 VSS.n1003 VSS.n323 0.430889
R4930 VSS.n1014 VSS.n323 0.430889
R4931 VSS.n1006 VSS.n323 0.430889
R4932 VSS.n1045 VSS.n391 0.430889
R4933 VSS.n1045 VSS.n392 0.430889
R4934 VSS.n1045 VSS.n393 0.430889
R4935 VSS.n1045 VSS.n1044 0.430889
R4936 VSS.n973 VSS.n957 0.430889
R4937 VSS.n973 VSS.n956 0.430889
R4938 VSS.n973 VSS.n955 0.430889
R4939 VSS.n974 VSS.n973 0.430889
R4940 VSS.n697 VSS.n679 0.430889
R4941 VSS.n697 VSS.n677 0.430889
R4942 VSS.n697 VSS.n696 0.430889
R4943 VSS.n825 VSS.n457 0.430889
R4944 VSS.n827 VSS.n457 0.430889
R4945 VSS.n833 VSS.n457 0.430889
R4946 VSS.n836 VSS.n457 0.430889
R4947 VSS.n819 VSS.n402 0.430889
R4948 VSS.n817 VSS.n402 0.430889
R4949 VSS.n811 VSS.n402 0.430889
R4950 VSS.n809 VSS.n402 0.430889
R4951 VSS.n461 VSS.n457 0.430889
R4952 VSS.n874 VSS.n457 0.430889
R4953 VSS.n464 VSS.n457 0.430889
R4954 VSS.n867 VSS.n457 0.430889
R4955 VSS.n504 VSS.n402 0.430889
R4956 VSS.n498 VSS.n402 0.430889
R4957 VSS.n496 VSS.n402 0.430889
R4958 VSS.n491 VSS.n402 0.430889
R4959 VSS.n941 VSS.n917 0.430889
R4960 VSS.n995 VSS.n994 0.430889
R4961 VSS.n1108 VSS.n294 0.430889
R4962 VSS.n1108 VSS.n295 0.430889
R4963 VSS.n1108 VSS.n296 0.430889
R4964 VSS.n1109 VSS.n1108 0.430889
R4965 VSS.n318 VSS.n291 0.430889
R4966 VSS.n206 VSS.t42 0.41
R4967 VSS.n206 VSS.t30 0.41
R4968 VSS.n241 VSS.t25 0.41
R4969 VSS.n241 VSS.t437 0.41
R4970 VSS.n243 VSS.t443 0.41
R4971 VSS.n243 VSS.t162 0.41
R4972 VSS.n274 VSS.t484 0.41
R4973 VSS.n274 VSS.t483 0.41
R4974 VSS.n242 VSS.n240 0.3875
R4975 VSS.n1119 VSS.n202 0.379447
R4976 VSS.n59 VSS.n58 0.379447
R4977 VSS.n1113 VSS.n1112 0.37175
R4978 VSS.n862 VSS.n861 0.37175
R4979 VSS.n864 VSS.n466 0.37175
R4980 VSS.n978 VSS.n977 0.37175
R4981 VSS.n245 VSS.n244 0.3695
R4982 VSS.n839 VSS.n467 0.366125
R4983 VSS.n847 VSS.n846 0.366125
R4984 VSS.n865 VSS.n465 0.366125
R4985 VSS.n506 VSS.n488 0.366125
R4986 VSS.n933 VSS.n929 0.3605
R4987 VSS.n1150 VSS.n125 0.3605
R4988 VSS.n598 VSS.n587 0.3605
R4989 VSS.n1251 VSS.n1250 0.3605
R4990 VSS.n792 VSS.n791 0.338
R4991 VSS.n1168 VSS.n1167 0.338
R4992 VSS.n727 VSS.n726 0.338
R4993 VSS.n616 VSS.n615 0.338
R4994 VSS.n934 VSS.n933 0.3155
R4995 VSS.n883 VSS.n451 0.3155
R4996 VSS.n879 VSS.n878 0.3155
R4997 VSS.n839 VSS.n838 0.309875
R4998 VSS.n846 VSS.n821 0.309875
R4999 VSS.n465 VSS.n463 0.309875
R5000 VSS.n502 VSS.n488 0.309875
R5001 VSS.n1113 VSS.n289 0.28175
R5002 VSS.n977 VSS.n976 0.28175
R5003 VSS.n1170 VSS.n121 0.2772
R5004 VSS.n1170 VSS.n120 0.2772
R5005 VSS.n1170 VSS.n119 0.2772
R5006 VSS.n1170 VSS.n118 0.2772
R5007 VSS.n1170 VSS.n117 0.2772
R5008 VSS.n796 VSS.n795 0.2772
R5009 VSS.n795 VSS.n516 0.2772
R5010 VSS.n795 VSS.n518 0.2772
R5011 VSS.n795 VSS.n519 0.2772
R5012 VSS.n724 VSS.n546 0.2772
R5013 VSS.n721 VSS.n546 0.2772
R5014 VSS.n550 VSS.n546 0.2772
R5015 VSS.n714 VSS.n546 0.2772
R5016 VSS.n708 VSS.n546 0.2772
R5017 VSS.n596 VSS.n589 0.2772
R5018 VSS.n602 VSS.n589 0.2772
R5019 VSS.n604 VSS.n589 0.2772
R5020 VSS.n610 VSS.n589 0.2772
R5021 VSS.n1191 VSS.n1174 0.2772
R5022 VSS.n1191 VSS.n1173 0.2772
R5023 VSS.n1191 VSS.n1172 0.2772
R5024 VSS.n1248 VSS.n1247 0.2772
R5025 VSS.n1247 VSS.n66 0.2772
R5026 VSS.n282 VSS.n279 0.2705
R5027 VSS.n279 VSS.n273 0.2705
R5028 VSS.n273 VSS.n269 0.2705
R5029 VSS.n215 VSS.n211 0.2705
R5030 VSS.n211 VSS.n205 0.2705
R5031 VSS.n259 VSS.n258 0.2345
R5032 VSS.n216 VSS.n215 0.2345
R5033 VSS.n1254 VSS.n0 0.2255
R5034 VSS.n1030 VSS.n1025 0.2255
R5035 VSS.n922 VSS.n289 0.2255
R5036 VSS.n227 VSS.n226 0.2165
R5037 VSS.n205 VSS.n60 0.206961
R5038 VSS.n145 VSS.t506 0.20525
R5039 VSS.n145 VSS.t504 0.20525
R5040 VSS.n146 VSS.t210 0.20525
R5041 VSS.n146 VSS.t208 0.20525
R5042 VSS.n148 VSS.t214 0.20525
R5043 VSS.n148 VSS.t212 0.20525
R5044 VSS.n151 VSS.t327 0.20525
R5045 VSS.n151 VSS.t325 0.20525
R5046 VSS.n152 VSS.t341 0.20525
R5047 VSS.n152 VSS.t339 0.20525
R5048 VSS.n154 VSS.t345 0.20525
R5049 VSS.n154 VSS.t343 0.20525
R5050 VSS.n157 VSS.t393 0.20525
R5051 VSS.n157 VSS.t391 0.20525
R5052 VSS.n161 VSS.t329 0.20525
R5053 VSS.n161 VSS.t301 0.20525
R5054 VSS.n160 VSS.t333 0.20525
R5055 VSS.n160 VSS.t331 0.20525
R5056 VSS.n165 VSS.t248 0.20525
R5057 VSS.n165 VSS.t250 0.20525
R5058 VSS.n166 VSS.t246 0.20525
R5059 VSS.n166 VSS.t247 0.20525
R5060 VSS.n168 VSS.t241 0.20525
R5061 VSS.n168 VSS.t242 0.20525
R5062 VSS.n169 VSS.t237 0.20525
R5063 VSS.n169 VSS.t239 0.20525
R5064 VSS.n170 VSS.t233 0.20525
R5065 VSS.n170 VSS.t235 0.20525
R5066 VSS.n172 VSS.t229 0.20525
R5067 VSS.n172 VSS.t231 0.20525
R5068 VSS.n177 VSS.t244 0.20525
R5069 VSS.n177 VSS.t245 0.20525
R5070 VSS.n188 VSS.t413 0.20525
R5071 VSS.n188 VSS.t411 0.20525
R5072 VSS.n189 VSS.t403 0.20525
R5073 VSS.n189 VSS.t415 0.20525
R5074 VSS.n191 VSS.t407 0.20525
R5075 VSS.n191 VSS.t405 0.20525
R5076 VSS.n194 VSS.t401 0.20525
R5077 VSS.n194 VSS.t409 0.20525
R5078 VSS.n197 VSS.t203 0.20525
R5079 VSS.n197 VSS.t201 0.20525
R5080 VSS.n198 VSS.t207 0.20525
R5081 VSS.n198 VSS.t205 0.20525
R5082 VSS.n200 VSS.t297 0.20525
R5083 VSS.n200 VSS.t295 0.20525
R5084 VSS.n184 VSS.t476 0.20525
R5085 VSS.n184 VSS.t489 0.20525
R5086 VSS.n183 VSS.t480 0.20525
R5087 VSS.n183 VSS.t478 0.20525
R5088 VSS.n180 VSS.t116 0.20525
R5089 VSS.n180 VSS.t118 0.20525
R5090 VSS.n53 VSS.t337 0.20525
R5091 VSS.n53 VSS.t335 0.20525
R5092 VSS.n55 VSS.t359 0.20525
R5093 VSS.n55 VSS.t357 0.20525
R5094 VSS.n54 VSS.t363 0.20525
R5095 VSS.n54 VSS.t361 0.20525
R5096 VSS.n44 VSS.t397 0.20525
R5097 VSS.n44 VSS.t395 0.20525
R5098 VSS.n48 VSS.t381 0.20525
R5099 VSS.n48 VSS.t399 0.20525
R5100 VSS.n46 VSS.t385 0.20525
R5101 VSS.n46 VSS.t383 0.20525
R5102 VSS.n45 VSS.t354 0.20525
R5103 VSS.n45 VSS.t387 0.20525
R5104 VSS.n39 VSS.t469 0.20525
R5105 VSS.n39 VSS.t168 0.20525
R5106 VSS.n40 VSS.t473 0.20525
R5107 VSS.n40 VSS.t471 0.20525
R5108 VSS.n21 VSS.t223 0.20525
R5109 VSS.n21 VSS.t225 0.20525
R5110 VSS.n22 VSS.t6 0.20525
R5111 VSS.n22 VSS.t14 0.20525
R5112 VSS.n24 VSS.t12 0.20525
R5113 VSS.n24 VSS.t8 0.20525
R5114 VSS.n23 VSS.t4 0.20525
R5115 VSS.n23 VSS.t10 0.20525
R5116 VSS.n32 VSS.t221 0.20525
R5117 VSS.n32 VSS.t222 0.20525
R5118 VSS.n30 VSS.t219 0.20525
R5119 VSS.n30 VSS.t220 0.20525
R5120 VSS.n29 VSS.t217 0.20525
R5121 VSS.n29 VSS.t218 0.20525
R5122 VSS.n36 VSS.t305 0.20525
R5123 VSS.n36 VSS.t307 0.20525
R5124 VSS.n7 VSS.t365 0.20525
R5125 VSS.n7 VSS.t373 0.20525
R5126 VSS.n11 VSS.t369 0.20525
R5127 VSS.n11 VSS.t367 0.20525
R5128 VSS.n9 VSS.t375 0.20525
R5129 VSS.n9 VSS.t371 0.20525
R5130 VSS.n8 VSS.t379 0.20525
R5131 VSS.n8 VSS.t377 0.20525
R5132 VSS.n1 VSS.t287 0.20525
R5133 VSS.n1 VSS.t199 0.20525
R5134 VSS.n3 VSS.t291 0.20525
R5135 VSS.n3 VSS.t289 0.20525
R5136 VSS.n2 VSS.t389 0.20525
R5137 VSS.n2 VSS.t293 0.20525
R5138 VSS.n16 VSS.t195 0.20525
R5139 VSS.n16 VSS.t193 0.20525
R5140 VSS.n17 VSS.t349 0.20525
R5141 VSS.n17 VSS.t347 0.20525
R5142 VSS.n203 VSS.t144 0.20525
R5143 VSS.n203 VSS.t178 0.20525
R5144 VSS.n218 VSS.t105 0.20525
R5145 VSS.n218 VSS.t89 0.20525
R5146 VSS.n217 VSS.t435 0.20525
R5147 VSS.n217 VSS.t196 0.20525
R5148 VSS.n223 VSS.t101 0.20525
R5149 VSS.n223 VSS.t103 0.20525
R5150 VSS.n221 VSS.t97 0.20525
R5151 VSS.n221 VSS.t99 0.20525
R5152 VSS.n220 VSS.t93 0.20525
R5153 VSS.n220 VSS.t95 0.20525
R5154 VSS.n232 VSS.t111 0.20525
R5155 VSS.n232 VSS.t113 0.20525
R5156 VSS.n230 VSS.t28 0.20525
R5157 VSS.n230 VSS.t26 0.20525
R5158 VSS.n228 VSS.t157 0.20525
R5159 VSS.n228 VSS.t155 0.20525
R5160 VSS.n237 VSS.t108 0.20525
R5161 VSS.n237 VSS.t109 0.20525
R5162 VSS.n235 VSS.t106 0.20525
R5163 VSS.n235 VSS.t107 0.20525
R5164 VSS.n234 VSS.t91 0.20525
R5165 VSS.n234 VSS.t87 0.20525
R5166 VSS.n212 VSS.t187 0.20525
R5167 VSS.n212 VSS.t189 0.20525
R5168 VSS.n213 VSS.t183 0.20525
R5169 VSS.n213 VSS.t185 0.20525
R5170 VSS.n207 VSS.t463 0.20525
R5171 VSS.n207 VSS.t465 0.20525
R5172 VSS.n208 VSS.t461 0.20525
R5173 VSS.n208 VSS.t462 0.20525
R5174 VSS.n261 VSS.t270 0.20525
R5175 VSS.n261 VSS.t272 0.20525
R5176 VSS.n260 VSS.t160 0.20525
R5177 VSS.n260 VSS.t175 0.20525
R5178 VSS.n266 VSS.t257 0.20525
R5179 VSS.n266 VSS.t268 0.20525
R5180 VSS.n264 VSS.t263 0.20525
R5181 VSS.n264 VSS.t266 0.20525
R5182 VSS.n263 VSS.t259 0.20525
R5183 VSS.n263 VSS.t265 0.20525
R5184 VSS.n246 VSS.t482 0.20525
R5185 VSS.n246 VSS.t419 0.20525
R5186 VSS.n250 VSS.t282 0.20525
R5187 VSS.n250 VSS.t284 0.20525
R5188 VSS.n247 VSS.t502 0.20525
R5189 VSS.n247 VSS.t19 0.20525
R5190 VSS.n252 VSS.t278 0.20525
R5191 VSS.n252 VSS.t280 0.20525
R5192 VSS.n254 VSS.t275 0.20525
R5193 VSS.n254 VSS.t276 0.20525
R5194 VSS.n253 VSS.t261 0.20525
R5195 VSS.n253 VSS.t274 0.20525
R5196 VSS.n270 VSS.t48 0.20525
R5197 VSS.n270 VSS.t54 0.20525
R5198 VSS.n271 VSS.t50 0.20525
R5199 VSS.n271 VSS.t52 0.20525
R5200 VSS.n280 VSS.t40 0.20525
R5201 VSS.n280 VSS.t36 0.20525
R5202 VSS.n275 VSS.t315 0.20525
R5203 VSS.n275 VSS.t309 0.20525
R5204 VSS.n276 VSS.t311 0.20525
R5205 VSS.n276 VSS.t313 0.20525
R5206 VSS.n844 VSS.n843 0.189974
R5207 VSS.n486 VSS.n485 0.189974
R5208 VSS.n179 VSS.n164 0.189974
R5209 VSS.n155 VSS.n153 0.189974
R5210 VSS.n178 VSS.n176 0.189974
R5211 VSS.n176 VSS.n167 0.189974
R5212 VSS.n192 VSS.n190 0.189974
R5213 VSS.n35 VSS.n20 0.189974
R5214 VSS.n49 VSS.n47 0.189974
R5215 VSS.n33 VSS.n31 0.189974
R5216 VSS.n34 VSS.n33 0.189974
R5217 VSS.n12 VSS.n10 0.189974
R5218 VSS.n224 VSS.n222 0.189974
R5219 VSS.n224 VSS.n219 0.189974
R5220 VSS.n238 VSS.n236 0.189974
R5221 VSS.n238 VSS.n233 0.189974
R5222 VSS.n267 VSS.n265 0.189974
R5223 VSS.n267 VSS.n262 0.189974
R5224 VSS.n256 VSS.n255 0.189974
R5225 VSS.n256 VSS.n251 0.189974
R5226 VSS.n371 VSS.n370 0.178383
R5227 VSS.n862 VSS.n467 0.16925
R5228 VSS.n865 VSS.n864 0.16925
R5229 VSS.n557 VSS.t457 0.1643
R5230 VSS.n557 VSS.t459 0.1643
R5231 VSS.n556 VSS.t447 0.1643
R5232 VSS.n556 VSS.t445 0.1643
R5233 VSS.n414 VSS.t453 0.1643
R5234 VSS.n414 VSS.t455 0.1643
R5235 VSS.n413 VSS.t449 0.1643
R5236 VSS.n413 VSS.t451 0.1643
R5237 VSS.n918 VSS.t80 0.1643
R5238 VSS.n918 VSS.t73 0.1643
R5239 VSS.n920 VSS.t75 0.1643
R5240 VSS.n920 VSS.t79 0.1643
R5241 VSS.n1026 VSS.t83 0.1643
R5242 VSS.n1026 VSS.t84 0.1643
R5243 VSS.n1027 VSS.t82 0.1643
R5244 VSS.n1027 VSS.t81 0.1643
R5245 VSS.n845 VSS.n840 0.1605
R5246 VSS.n487 VSS.n482 0.1605
R5247 VSS.n1252 VSS.n60 0.144074
R5248 VSS.n841 VSS.t426 0.137
R5249 VSS.n841 VSS.t428 0.137
R5250 VSS.n842 VSS.t422 0.137
R5251 VSS.n842 VSS.t424 0.137
R5252 VSS.n483 VSS.t431 0.137
R5253 VSS.n483 VSS.t432 0.137
R5254 VSS.n484 VSS.t430 0.137
R5255 VSS.n484 VSS.t429 0.137
R5256 VSS.n1029 VSS.n1028 0.118945
R5257 VSS.n921 VSS.n919 0.117954
R5258 VSS.n976 VSS.n416 0.113
R5259 VSS.n699 VSS.n559 0.113
R5260 VSS.n196 VSS.n187 0.0952368
R5261 VSS.n159 VSS.n150 0.0952368
R5262 VSS.n149 VSS.n147 0.0952368
R5263 VSS.n158 VSS.n156 0.0952368
R5264 VSS.n156 VSS.n155 0.0952368
R5265 VSS.n173 VSS.n171 0.0952368
R5266 VSS.n195 VSS.n193 0.0952368
R5267 VSS.n193 VSS.n192 0.0952368
R5268 VSS.n201 VSS.n199 0.0952368
R5269 VSS.n15 VSS.n6 0.0952368
R5270 VSS.n52 VSS.n43 0.0952368
R5271 VSS.n57 VSS.n56 0.0952368
R5272 VSS.n50 VSS.n49 0.0952368
R5273 VSS.n51 VSS.n50 0.0952368
R5274 VSS.n26 VSS.n25 0.0952368
R5275 VSS.n13 VSS.n12 0.0952368
R5276 VSS.n14 VSS.n13 0.0952368
R5277 VSS.n5 VSS.n4 0.0952368
R5278 VSS.n258 VSS.n245 0.0545
R5279 VSS.n240 VSS.n227 0.0545
R5280 VSS VSS.n1254 0.0455
R5281 VSS.n285 VSS.n283 0.0436507
R5282 VSS.n288 VSS.n283 0.0436507
R5283 VSS.n269 VSS.n259 0.0365
R5284 VSS.n226 VSS.n216 0.0365
R5285 VSS.n1116 VSS.n283 0.008375
R5286 VSS.n1114 VSS.n284 0.004
R5287 VSS.n1115 VSS.n1114 0.004
R5288 a_n6400_n23452.n1 a_n6400_n23452.t4 16.0839
R5289 a_n6400_n23452.n1 a_n6400_n23452.n0 12.3065
R5290 a_n6400_n23452.n2 a_n6400_n23452.n1 10.9378
R5291 a_n6400_n23452.n0 a_n6400_n23452.t2 0.1825
R5292 a_n6400_n23452.n0 a_n6400_n23452.t3 0.1825
R5293 a_n6400_n23452.n2 a_n6400_n23452.t1 0.1643
R5294 a_n6400_n23452.t0 a_n6400_n23452.n2 0.1643
R5295 a_n7157_n23500.n1 a_n7157_n23500.t1 16.0839
R5296 a_n7157_n23500.n0 a_n7157_n23500.t2 6.66284
R5297 a_n7157_n23500.t3 a_n7157_n23500.n2 6.62866
R5298 a_n7157_n23500.n0 a_n7157_n23500.t0 6.45713
R5299 a_n7157_n23500.n2 a_n7157_n23500.t4 6.42295
R5300 a_n7157_n23500.n1 a_n7157_n23500.n0 5.97129
R5301 a_n7157_n23500.n2 a_n7157_n23500.n1 4.55024
R5302 a_n10800_n23372.n0 a_n10800_n23372.t3 139.69
R5303 a_n10800_n23372.n0 a_n10800_n23372.t2 139.69
R5304 a_n10800_n23372.n1 a_n10800_n23372.n0 36.7175
R5305 a_n10800_n23372.n1 a_n10800_n23372.t1 14.2148
R5306 a_n10800_n23372.t0 a_n10800_n23372.n1 11.6368
R5307 a_n6400_n21652.n1 a_n6400_n21652.t0 16.0839
R5308 a_n6400_n21652.n1 a_n6400_n21652.n0 12.3065
R5309 a_n6400_n21652.n2 a_n6400_n21652.n1 10.9378
R5310 a_n6400_n21652.n0 a_n6400_n21652.t4 0.1825
R5311 a_n6400_n21652.n0 a_n6400_n21652.t3 0.1825
R5312 a_n6400_n21652.t1 a_n6400_n21652.n2 0.1643
R5313 a_n6400_n21652.n2 a_n6400_n21652.t2 0.1643
R5314 a_n7157_n21700.n1 a_n7157_n21700.t0 16.0839
R5315 a_n7157_n21700.n0 a_n7157_n21700.t1 6.66284
R5316 a_n7157_n21700.t3 a_n7157_n21700.n2 6.62866
R5317 a_n7157_n21700.n0 a_n7157_n21700.t2 6.45713
R5318 a_n7157_n21700.n2 a_n7157_n21700.t4 6.42295
R5319 a_n7157_n21700.n1 a_n7157_n21700.n0 5.97129
R5320 a_n7157_n21700.n2 a_n7157_n21700.n1 4.55024
R5321 a_n10800_n21572.n0 a_n10800_n21572.t3 139.69
R5322 a_n10800_n21572.n0 a_n10800_n21572.t2 139.69
R5323 a_n10800_n21572.n1 a_n10800_n21572.n0 36.7175
R5324 a_n10800_n21572.n1 a_n10800_n21572.t1 14.2148
R5325 a_n10800_n21572.t0 a_n10800_n21572.n1 11.6368
R5326 a_n6400_n19852.n1 a_n6400_n19852.t2 16.1006
R5327 a_n6400_n19852.n1 a_n6400_n19852.n0 12.3065
R5328 a_n6400_n19852.n2 a_n6400_n19852.n1 10.9378
R5329 a_n6400_n19852.n0 a_n6400_n19852.t3 0.1825
R5330 a_n6400_n19852.n0 a_n6400_n19852.t4 0.1825
R5331 a_n6400_n19852.t0 a_n6400_n19852.n2 0.1643
R5332 a_n6400_n19852.n2 a_n6400_n19852.t1 0.1643
R5333 a_n7300_n19900.n1 a_n7300_n19900.t0 16.1006
R5334 a_n7300_n19900.n0 a_n7300_n19900.t1 6.66284
R5335 a_n7300_n19900.t3 a_n7300_n19900.n2 6.62866
R5336 a_n7300_n19900.n0 a_n7300_n19900.t2 6.45713
R5337 a_n7300_n19900.n2 a_n7300_n19900.t4 6.42295
R5338 a_n7300_n19900.n1 a_n7300_n19900.n0 5.97129
R5339 a_n7300_n19900.n2 a_n7300_n19900.n1 4.55024
R5340 a_n10800_n19772.n0 a_n10800_n19772.t3 139.69
R5341 a_n10800_n19772.n0 a_n10800_n19772.t2 139.69
R5342 a_n10800_n19772.n1 a_n10800_n19772.n0 36.7175
R5343 a_n10800_n19772.n1 a_n10800_n19772.t1 14.2148
R5344 a_n10800_n19772.t0 a_n10800_n19772.n1 11.6368
R5345 a_n6400_n18052.n1 a_n6400_n18052.t0 16.1006
R5346 a_n6400_n18052.n2 a_n6400_n18052.n1 12.3065
R5347 a_n6400_n18052.n1 a_n6400_n18052.n0 10.9378
R5348 a_n6400_n18052.n2 a_n6400_n18052.t2 0.1825
R5349 a_n6400_n18052.t1 a_n6400_n18052.n2 0.1825
R5350 a_n6400_n18052.n0 a_n6400_n18052.t3 0.1643
R5351 a_n6400_n18052.n0 a_n6400_n18052.t4 0.1643
R5352 a_n7300_n18100.n1 a_n7300_n18100.t3 16.1006
R5353 a_n7300_n18100.n0 a_n7300_n18100.t2 6.66284
R5354 a_n7300_n18100.n2 a_n7300_n18100.t0 6.62866
R5355 a_n7300_n18100.n0 a_n7300_n18100.t4 6.45713
R5356 a_n7300_n18100.t1 a_n7300_n18100.n2 6.42295
R5357 a_n7300_n18100.n1 a_n7300_n18100.n0 5.97129
R5358 a_n7300_n18100.n2 a_n7300_n18100.n1 4.55024
R5359 a_n10800_n17972.n0 a_n10800_n17972.t3 139.69
R5360 a_n10800_n17972.n0 a_n10800_n17972.t2 139.69
R5361 a_n10800_n17972.n1 a_n10800_n17972.n0 36.7175
R5362 a_n10800_n17972.n1 a_n10800_n17972.t1 14.2148
R5363 a_n10800_n17972.t0 a_n10800_n17972.n1 11.6368
R5364 a_n6400_n16252.n1 a_n6400_n16252.t0 16.1006
R5365 a_n6400_n16252.n1 a_n6400_n16252.n0 12.3065
R5366 a_n6400_n16252.n2 a_n6400_n16252.n1 10.9378
R5367 a_n6400_n16252.n0 a_n6400_n16252.t4 0.1825
R5368 a_n6400_n16252.n0 a_n6400_n16252.t3 0.1825
R5369 a_n6400_n16252.n2 a_n6400_n16252.t2 0.1643
R5370 a_n6400_n16252.t1 a_n6400_n16252.n2 0.1643
R5371 a_n7300_n16300.n1 a_n7300_n16300.t0 16.1006
R5372 a_n7300_n16300.n0 a_n7300_n16300.t2 6.66284
R5373 a_n7300_n16300.t3 a_n7300_n16300.n2 6.62866
R5374 a_n7300_n16300.n0 a_n7300_n16300.t1 6.45713
R5375 a_n7300_n16300.n2 a_n7300_n16300.t4 6.42295
R5376 a_n7300_n16300.n1 a_n7300_n16300.n0 5.97129
R5377 a_n7300_n16300.n2 a_n7300_n16300.n1 4.55024
R5378 a_n10800_n16172.n0 a_n10800_n16172.t3 139.69
R5379 a_n10800_n16172.n0 a_n10800_n16172.t2 139.69
R5380 a_n10800_n16172.n1 a_n10800_n16172.n0 36.7175
R5381 a_n10800_n16172.n1 a_n10800_n16172.t1 14.2148
R5382 a_n10800_n16172.t0 a_n10800_n16172.n1 11.6368
R5383 a_n6400_n14452.n1 a_n6400_n14452.t0 16.1006
R5384 a_n6400_n14452.n2 a_n6400_n14452.n1 12.3065
R5385 a_n6400_n14452.n1 a_n6400_n14452.n0 10.9378
R5386 a_n6400_n14452.n2 a_n6400_n14452.t2 0.1825
R5387 a_n6400_n14452.t1 a_n6400_n14452.n2 0.1825
R5388 a_n6400_n14452.n0 a_n6400_n14452.t4 0.1643
R5389 a_n6400_n14452.n0 a_n6400_n14452.t3 0.1643
R5390 a_n7300_n14500.n1 a_n7300_n14500.t4 16.1006
R5391 a_n7300_n14500.n0 a_n7300_n14500.t3 6.66284
R5392 a_n7300_n14500.n2 a_n7300_n14500.t0 6.62866
R5393 a_n7300_n14500.n0 a_n7300_n14500.t2 6.45713
R5394 a_n7300_n14500.t1 a_n7300_n14500.n2 6.42295
R5395 a_n7300_n14500.n1 a_n7300_n14500.n0 5.97129
R5396 a_n7300_n14500.n2 a_n7300_n14500.n1 4.55024
R5397 a_n10800_n14372.n0 a_n10800_n14372.t3 139.69
R5398 a_n10800_n14372.n0 a_n10800_n14372.t2 139.69
R5399 a_n10800_n14372.n1 a_n10800_n14372.n0 36.7175
R5400 a_n10800_n14372.n1 a_n10800_n14372.t1 14.2148
R5401 a_n10800_n14372.t0 a_n10800_n14372.n1 11.6368
R5402 a_n6400_n12652.n1 a_n6400_n12652.t0 16.1006
R5403 a_n6400_n12652.n2 a_n6400_n12652.n1 12.3065
R5404 a_n6400_n12652.n1 a_n6400_n12652.n0 10.9378
R5405 a_n6400_n12652.t1 a_n6400_n12652.n2 0.1825
R5406 a_n6400_n12652.n2 a_n6400_n12652.t2 0.1825
R5407 a_n6400_n12652.n0 a_n6400_n12652.t3 0.1643
R5408 a_n6400_n12652.n0 a_n6400_n12652.t4 0.1643
R5409 a_n7300_n12700.n1 a_n7300_n12700.t0 16.1006
R5410 a_n7300_n12700.n0 a_n7300_n12700.t3 6.66284
R5411 a_n7300_n12700.n2 a_n7300_n12700.t1 6.62866
R5412 a_n7300_n12700.n0 a_n7300_n12700.t4 6.45713
R5413 a_n7300_n12700.t2 a_n7300_n12700.n2 6.42295
R5414 a_n7300_n12700.n1 a_n7300_n12700.n0 5.97129
R5415 a_n7300_n12700.n2 a_n7300_n12700.n1 4.55024
R5416 a_n10800_n12572.n0 a_n10800_n12572.t3 139.69
R5417 a_n10800_n12572.n0 a_n10800_n12572.t2 139.69
R5418 a_n10800_n12572.n1 a_n10800_n12572.n0 36.7175
R5419 a_n10800_n12572.n1 a_n10800_n12572.t1 14.2148
R5420 a_n10800_n12572.t0 a_n10800_n12572.n1 11.6368
R5421 a_2148_n500.n5 a_2148_n500.n3 10.5451
R5422 a_2148_n500.n5 a_2148_n500.n4 10.5451
R5423 a_2148_n500.n2 a_2148_n500.t0 6.45713
R5424 a_2148_n500.n8 a_2148_n500.n7 6.38754
R5425 a_2148_n500.n1 a_2148_n500.n0 6.29333
R5426 a_2148_n500.n6 a_2148_n500.n2 4.68405
R5427 a_2148_n500.n7 a_2148_n500.n6 2.22659
R5428 a_2148_n500.n6 a_2148_n500.n5 0.8055
R5429 a_2148_n500.n3 a_2148_n500.t7 0.3281
R5430 a_2148_n500.n3 a_2148_n500.t5 0.3281
R5431 a_2148_n500.n4 a_2148_n500.t8 0.3281
R5432 a_2148_n500.n4 a_2148_n500.t6 0.3281
R5433 a_2148_n500.n2 a_2148_n500.n1 0.189974
R5434 a_2148_n500.n8 a_2148_n500.t3 0.1643
R5435 a_2148_n500.t4 a_2148_n500.n8 0.1643
R5436 a_2148_n500.n0 a_2148_n500.t1 0.1643
R5437 a_2148_n500.n0 a_2148_n500.t2 0.1643
R5438 a_2148_n500.n7 a_2148_n500.n1 0.0928953
R5439 a_n5052_n1000.n5 a_n5052_n1000.n3 11.1933
R5440 a_n5052_n1000.n5 a_n5052_n1000.n4 11.1933
R5441 a_n5052_n1000.n2 a_n5052_n1000.t2 6.45713
R5442 a_n5052_n1000.n8 a_n5052_n1000.n7 6.38754
R5443 a_n5052_n1000.n1 a_n5052_n1000.n0 6.29333
R5444 a_n5052_n1000.n6 a_n5052_n1000.n2 4.68405
R5445 a_n5052_n1000.n7 a_n5052_n1000.n6 2.22659
R5446 a_n5052_n1000.n6 a_n5052_n1000.n5 0.5555
R5447 a_n5052_n1000.n2 a_n5052_n1000.n1 0.189974
R5448 a_n5052_n1000.n8 a_n5052_n1000.t5 0.1643
R5449 a_n5052_n1000.t6 a_n5052_n1000.n8 0.1643
R5450 a_n5052_n1000.n0 a_n5052_n1000.t3 0.1643
R5451 a_n5052_n1000.n0 a_n5052_n1000.t4 0.1643
R5452 a_n5052_n1000.n3 a_n5052_n1000.t8 0.1643
R5453 a_n5052_n1000.n3 a_n5052_n1000.t7 0.1643
R5454 a_n5052_n1000.n4 a_n5052_n1000.t0 0.1643
R5455 a_n5052_n1000.n4 a_n5052_n1000.t1 0.1643
R5456 a_n5052_n1000.n7 a_n5052_n1000.n1 0.0928953
R5457 a_n5052_2600.t3 a_n5052_2600.n4 7.27134
R5458 a_n5052_2600.n4 a_n5052_2600.t0 7.27134
R5459 a_n5052_2600.n2 a_n5052_2600.n0 6.71615
R5460 a_n5052_2600.n2 a_n5052_2600.n1 6.71615
R5461 a_n5052_2600.n4 a_n5052_2600.n3 6.31615
R5462 a_n5052_2600.n0 a_n5052_2600.t6 0.8195
R5463 a_n5052_2600.n0 a_n5052_2600.t7 0.8195
R5464 a_n5052_2600.n1 a_n5052_2600.t4 0.8195
R5465 a_n5052_2600.n1 a_n5052_2600.t5 0.8195
R5466 a_n5052_2600.n3 a_n5052_2600.t1 0.8195
R5467 a_n5052_2600.n3 a_n5052_2600.t2 0.8195
R5468 a_n5052_2600.n4 a_n5052_2600.n2 0.3955
R5469 a_5300_5958.t1 a_5300_5958.t0 26.7478
R5470 a_484_3500.t1 a_484_3500.t0 26.7478
R5471 a_n1900_5958.t1 a_n1900_5958.t0 26.7478
R5472 a_n3600_5641.n3 a_n3600_5641.t6 74.5091
R5473 a_n3600_5641.n3 a_n3600_5641.t7 74.5091
R5474 a_n3600_5641.n4 a_n3600_5641.n3 37.8057
R5475 a_n3600_5641.n1 a_n3600_5641.t4 13.0154
R5476 a_n3600_5641.n1 a_n3600_5641.t5 10.6142
R5477 a_n3600_5641.n0 a_n3600_5641.t2 7.23009
R5478 a_n3600_5641.n0 a_n3600_5641.t3 7.22685
R5479 a_n3600_5641.n5 a_n3600_5641.t0 6.55206
R5480 a_n3600_5641.t1 a_n3600_5641.n5 6.54882
R5481 a_n3600_5641.n5 a_n3600_5641.n4 2.75982
R5482 a_n3600_5641.n2 a_n3600_5641.n0 2.26891
R5483 a_n3600_5641.n2 a_n3600_5641.n1 0.425955
R5484 a_n3600_5641.n4 a_n3600_5641.n2 0.393227
R5485 a_n6572_3500.n3 a_n6572_3500.t6 74.5091
R5486 a_n6572_3500.n3 a_n6572_3500.t7 74.5091
R5487 a_n6572_3500.n4 a_n6572_3500.n3 37.5518
R5488 a_n6572_3500.n1 a_n6572_3500.t4 13.0154
R5489 a_n6572_3500.n1 a_n6572_3500.t5 10.6142
R5490 a_n6572_3500.n0 a_n6572_3500.t3 7.23009
R5491 a_n6572_3500.n0 a_n6572_3500.t2 7.22685
R5492 a_n6572_3500.t1 a_n6572_3500.n5 6.55206
R5493 a_n6572_3500.n5 a_n6572_3500.t0 6.54882
R5494 a_n6572_3500.n5 a_n6572_3500.n4 2.59618
R5495 a_n6572_3500.n2 a_n6572_3500.n0 2.26891
R5496 a_n6572_3500.n4 a_n6572_3500.n2 0.556864
R5497 a_n6572_3500.n2 a_n6572_3500.n1 0.425955
R5498 a_n6716_3500.t1 a_n6716_3500.t0 26.7478
R5499 a_n852_19400.n5 a_n852_19400.n3 10.7042
R5500 a_n852_19400.n5 a_n852_19400.n4 10.7042
R5501 a_n852_19400.t5 a_n852_19400.n7 6.77
R5502 a_n852_19400.n2 a_n852_19400.t2 6.6753
R5503 a_n852_19400.n1 a_n852_19400.n0 6.5388
R5504 a_n852_19400.n6 a_n852_19400.n2 4.63668
R5505 a_n852_19400.n7 a_n852_19400.n6 2.23814
R5506 a_n852_19400.n6 a_n852_19400.n5 0.5055
R5507 a_n852_19400.n2 a_n852_19400.n1 0.189974
R5508 a_n852_19400.n3 a_n852_19400.t7 0.1643
R5509 a_n852_19400.n3 a_n852_19400.t6 0.1643
R5510 a_n852_19400.n4 a_n852_19400.t1 0.1643
R5511 a_n852_19400.n4 a_n852_19400.t0 0.1643
R5512 a_n852_19400.n0 a_n852_19400.t3 0.137
R5513 a_n852_19400.n0 a_n852_19400.t4 0.137
R5514 a_n852_19400.n7 a_n852_19400.n1 0.0924286
R5515 a_n852_28800.n3 a_n852_28800.n1 10.7042
R5516 a_n852_28800.n3 a_n852_28800.n2 10.7042
R5517 a_n852_28800.n0 a_n852_28800.t7 6.77
R5518 a_n852_28800.n5 a_n852_28800.t4 6.6753
R5519 a_n852_28800.n7 a_n852_28800.n6 6.5388
R5520 a_n852_28800.n5 a_n852_28800.n4 4.63668
R5521 a_n852_28800.n4 a_n852_28800.n0 2.23814
R5522 a_n852_28800.n4 a_n852_28800.n3 0.5055
R5523 a_n852_28800.n6 a_n852_28800.n5 0.189974
R5524 a_n852_28800.n1 a_n852_28800.t1 0.1643
R5525 a_n852_28800.n1 a_n852_28800.t0 0.1643
R5526 a_n852_28800.n2 a_n852_28800.t2 0.1643
R5527 a_n852_28800.n2 a_n852_28800.t3 0.1643
R5528 a_n852_28800.n7 a_n852_28800.t5 0.137
R5529 a_n852_28800.t6 a_n852_28800.n7 0.137
R5530 a_n852_28800.n6 a_n852_28800.n0 0.0924286
R5531 a_600_22678.n0 a_600_22678.t4 139.689
R5532 a_600_22678.n0 a_600_22678.t3 139.689
R5533 a_600_22678.n1 a_600_22678.n0 37.2961
R5534 a_600_22678.n1 a_600_22678.t2 12.557
R5535 a_600_22678.n2 a_600_22678.t0 6.0613
R5536 a_600_22678.t1 a_600_22678.n2 6.0613
R5537 a_600_22678.n2 a_600_22678.n1 2.78832
R5538 a_n1000_22678.n0 a_n1000_22678.t4 139.689
R5539 a_n1000_22678.n0 a_n1000_22678.t3 139.689
R5540 a_n1000_22678.n1 a_n1000_22678.n0 37.2961
R5541 a_n1000_22678.n1 a_n1000_22678.t2 12.557
R5542 a_n1000_22678.n2 a_n1000_22678.t0 6.0613
R5543 a_n1000_22678.t1 a_n1000_22678.n2 6.0613
R5544 a_n1000_22678.n2 a_n1000_22678.n1 2.78832
R5545 a_11748_41600.n3 a_11748_41600.n1 10.7791
R5546 a_11748_41600.n3 a_11748_41600.n2 10.7791
R5547 a_11748_41600.n0 a_11748_41600.t7 6.55182
R5548 a_11748_41600.n5 a_11748_41600.t4 6.45713
R5549 a_11748_41600.n7 a_11748_41600.n6 6.29333
R5550 a_11748_41600.n5 a_11748_41600.n4 4.63668
R5551 a_11748_41600.n4 a_11748_41600.n0 2.23814
R5552 a_11748_41600.n4 a_11748_41600.n3 0.3305
R5553 a_11748_41600.n1 a_11748_41600.t0 0.20525
R5554 a_11748_41600.n1 a_11748_41600.t1 0.20525
R5555 a_11748_41600.n2 a_11748_41600.t3 0.20525
R5556 a_11748_41600.n2 a_11748_41600.t2 0.20525
R5557 a_11748_41600.n6 a_11748_41600.n5 0.189974
R5558 a_11748_41600.n7 a_11748_41600.t5 0.1643
R5559 a_11748_41600.t6 a_11748_41600.n7 0.1643
R5560 a_11748_41600.n6 a_11748_41600.n0 0.0924286
R5561 a_2148_41600.n3 a_2148_41600.n1 10.7791
R5562 a_2148_41600.n3 a_2148_41600.n2 10.7791
R5563 a_2148_41600.n0 a_2148_41600.t7 6.55182
R5564 a_2148_41600.n5 a_2148_41600.t4 6.45713
R5565 a_2148_41600.n7 a_2148_41600.n6 6.29333
R5566 a_2148_41600.n5 a_2148_41600.n4 4.63668
R5567 a_2148_41600.n4 a_2148_41600.n0 2.23814
R5568 a_2148_41600.n4 a_2148_41600.n3 0.3305
R5569 a_2148_41600.n1 a_2148_41600.t3 0.20525
R5570 a_2148_41600.n1 a_2148_41600.t2 0.20525
R5571 a_2148_41600.n2 a_2148_41600.t1 0.20525
R5572 a_2148_41600.n2 a_2148_41600.t0 0.20525
R5573 a_2148_41600.n6 a_2148_41600.n5 0.189974
R5574 a_2148_41600.n7 a_2148_41600.t5 0.1643
R5575 a_2148_41600.t6 a_2148_41600.n7 0.1643
R5576 a_2148_41600.n6 a_2148_41600.n0 0.0924286
R5577 a_12148_44200.n2 a_12148_44200.n0 15.3662
R5578 a_12148_44200.n2 a_12148_44200.n1 14.5662
R5579 a_12148_44200.n3 a_12148_44200.n2 7.70696
R5580 a_12148_44200.n3 a_12148_44200.t5 5.9772
R5581 a_12148_44200.t4 a_12148_44200.n3 5.9772
R5582 a_12148_44200.n0 a_12148_44200.t3 0.2735
R5583 a_12148_44200.n0 a_12148_44200.t2 0.2735
R5584 a_12148_44200.n1 a_12148_44200.t1 0.2735
R5585 a_12148_44200.n1 a_12148_44200.t0 0.2735
R5586 a_10548_44200.n2 a_10548_44200.n0 19.8662
R5587 a_10548_44200.n2 a_10548_44200.n1 19.3329
R5588 a_10548_44200.n3 a_10548_44200.n2 11.5875
R5589 a_10548_44200.n3 a_10548_44200.t5 5.9772
R5590 a_10548_44200.t4 a_10548_44200.n3 5.9772
R5591 a_10548_44200.n1 a_10548_44200.t3 0.2735
R5592 a_10548_44200.n1 a_10548_44200.t2 0.2735
R5593 a_10548_44200.n0 a_10548_44200.t1 0.2735
R5594 a_10548_44200.n0 a_10548_44200.t0 0.2735
R5595 a_2548_44200.n2 a_2548_44200.n0 15.3662
R5596 a_2548_44200.n2 a_2548_44200.n1 14.5662
R5597 a_2548_44200.n3 a_2548_44200.n2 7.70696
R5598 a_2548_44200.n3 a_2548_44200.t2 5.9772
R5599 a_2548_44200.t3 a_2548_44200.n3 5.9772
R5600 a_2548_44200.n0 a_2548_44200.t5 0.2735
R5601 a_2548_44200.n0 a_2548_44200.t4 0.2735
R5602 a_2548_44200.n1 a_2548_44200.t1 0.2735
R5603 a_2548_44200.n1 a_2548_44200.t0 0.2735
R5604 a_948_44200.n2 a_948_44200.n0 19.8662
R5605 a_948_44200.n2 a_948_44200.n1 19.3329
R5606 a_948_44200.n3 a_948_44200.n2 11.5875
R5607 a_948_44200.n3 a_948_44200.t5 5.9772
R5608 a_948_44200.t4 a_948_44200.n3 5.9772
R5609 a_948_44200.n1 a_948_44200.t3 0.2735
R5610 a_948_44200.n1 a_948_44200.t2 0.2735
R5611 a_948_44200.n0 a_948_44200.t1 0.2735
R5612 a_948_44200.n0 a_948_44200.t0 0.2735
R5613 XFRONT.XFE_O.NTAIL.n2 XFRONT.XFE_O.NTAIL.n0 20.6105
R5614 XFRONT.XFE_O.NTAIL.n10 XFRONT.XFE_O.NTAIL.n9 18.5365
R5615 XFRONT.XFE_O.NTAIL.n8 XFRONT.XFE_O.NTAIL.n7 10.6141
R5616 XFRONT.XFE_O.NTAIL.n2 XFRONT.XFE_O.NTAIL.n1 10.6141
R5617 XFRONT.XFE_O.NTAIL.n4 XFRONT.XFE_O.NTAIL.t5 5.7796
R5618 XFRONT.XFE_O.NTAIL.n1 XFRONT.XFE_O.NTAIL.t11 5.7796
R5619 XFRONT.XFE_O.NTAIL.n7 XFRONT.XFE_O.NTAIL.t0 5.68486
R5620 XFRONT.XFE_O.NTAIL.n1 XFRONT.XFE_O.NTAIL.t10 5.59012
R5621 XFRONT.XFE_O.NTAIL.n4 XFRONT.XFE_O.NTAIL.n3 5.38537
R5622 XFRONT.XFE_O.NTAIL.n6 XFRONT.XFE_O.NTAIL.n5 5.38537
R5623 XFRONT.XFE_O.NTAIL.n8 XFRONT.XFE_O.NTAIL.n2 2.50485
R5624 XFRONT.XFE_O.NTAIL.n10 XFRONT.XFE_O.NTAIL.n8 1.2918
R5625 XFRONT.XFE_O.NTAIL.n0 XFRONT.XFE_O.NTAIL.t9 0.20525
R5626 XFRONT.XFE_O.NTAIL.n0 XFRONT.XFE_O.NTAIL.t8 0.20525
R5627 XFRONT.XFE_O.NTAIL.n9 XFRONT.XFE_O.NTAIL.t7 0.20525
R5628 XFRONT.XFE_O.NTAIL.n9 XFRONT.XFE_O.NTAIL.t6 0.20525
R5629 XFRONT.XFE_O.NTAIL.n3 XFRONT.XFE_O.NTAIL.t3 0.20525
R5630 XFRONT.XFE_O.NTAIL.n3 XFRONT.XFE_O.NTAIL.t4 0.20525
R5631 XFRONT.XFE_O.NTAIL.n5 XFRONT.XFE_O.NTAIL.t1 0.20525
R5632 XFRONT.XFE_O.NTAIL.n5 XFRONT.XFE_O.NTAIL.t2 0.20525
R5633 XFRONT.XFE_O.NTAIL.n6 XFRONT.XFE_O.NTAIL.n4 0.189974
R5634 XFRONT.XFE_O.NTAIL.n7 XFRONT.XFE_O.NTAIL.n6 0.0952368
R5635 XFRONT.XFE_O.NTAIL XFRONT.XFE_O.NTAIL.n10 0.0396304
R5636 XFRONT.XFE_E.NTAIL.n3 XFRONT.XFE_E.NTAIL.n1 20.6105
R5637 XFRONT.XFE_E.NTAIL XFRONT.XFE_E.NTAIL.n0 18.5757
R5638 XFRONT.XFE_E.NTAIL.n9 XFRONT.XFE_E.NTAIL.n8 10.6141
R5639 XFRONT.XFE_E.NTAIL.n3 XFRONT.XFE_E.NTAIL.n2 10.6141
R5640 XFRONT.XFE_E.NTAIL.n2 XFRONT.XFE_E.NTAIL.t0 5.7796
R5641 XFRONT.XFE_E.NTAIL.n5 XFRONT.XFE_E.NTAIL.t4 5.7796
R5642 XFRONT.XFE_E.NTAIL.n8 XFRONT.XFE_E.NTAIL.t9 5.68486
R5643 XFRONT.XFE_E.NTAIL.n2 XFRONT.XFE_E.NTAIL.t1 5.59012
R5644 XFRONT.XFE_E.NTAIL.n7 XFRONT.XFE_E.NTAIL.n6 5.38537
R5645 XFRONT.XFE_E.NTAIL.n5 XFRONT.XFE_E.NTAIL.n4 5.38537
R5646 XFRONT.XFE_E.NTAIL.n9 XFRONT.XFE_E.NTAIL.n3 2.50485
R5647 XFRONT.XFE_E.NTAIL XFRONT.XFE_E.NTAIL.n9 1.25267
R5648 XFRONT.XFE_E.NTAIL.n0 XFRONT.XFE_E.NTAIL.t10 0.20525
R5649 XFRONT.XFE_E.NTAIL.n0 XFRONT.XFE_E.NTAIL.t11 0.20525
R5650 XFRONT.XFE_E.NTAIL.n1 XFRONT.XFE_E.NTAIL.t3 0.20525
R5651 XFRONT.XFE_E.NTAIL.n1 XFRONT.XFE_E.NTAIL.t2 0.20525
R5652 XFRONT.XFE_E.NTAIL.n6 XFRONT.XFE_E.NTAIL.t7 0.20525
R5653 XFRONT.XFE_E.NTAIL.n6 XFRONT.XFE_E.NTAIL.t8 0.20525
R5654 XFRONT.XFE_E.NTAIL.n4 XFRONT.XFE_E.NTAIL.t5 0.20525
R5655 XFRONT.XFE_E.NTAIL.n4 XFRONT.XFE_E.NTAIL.t6 0.20525
R5656 XFRONT.XFE_E.NTAIL.n7 XFRONT.XFE_E.NTAIL.n5 0.189974
R5657 XFRONT.XFE_E.NTAIL.n8 XFRONT.XFE_E.NTAIL.n7 0.0952368
R5658 XFRONT.XFE_O.BN.n16 XFRONT.XFE_O.BN.t10 113.632
R5659 XFRONT.XFE_O.BN.n2 XFRONT.XFE_O.BN.t23 113.632
R5660 XFRONT.XFE_O.BN.n6 XFRONT.XFE_O.BN.t16 113.632
R5661 XFRONT.XFE_O.BN.n21 XFRONT.XFE_O.BN.t15 109.174
R5662 XFRONT.XFE_O.BN.n20 XFRONT.XFE_O.BN.t14 109.174
R5663 XFRONT.XFE_O.BN.n19 XFRONT.XFE_O.BN.t13 109.174
R5664 XFRONT.XFE_O.BN.n14 XFRONT.XFE_O.BN.t12 109.174
R5665 XFRONT.XFE_O.BN.n15 XFRONT.XFE_O.BN.t11 109.174
R5666 XFRONT.XFE_O.BN.n9 XFRONT.XFE_O.BN.t19 109.174
R5667 XFRONT.XFE_O.BN.n10 XFRONT.XFE_O.BN.t20 109.174
R5668 XFRONT.XFE_O.BN.n3 XFRONT.XFE_O.BN.t22 109.174
R5669 XFRONT.XFE_O.BN.n4 XFRONT.XFE_O.BN.t21 109.174
R5670 XFRONT.XFE_O.BN.n8 XFRONT.XFE_O.BN.t18 109.174
R5671 XFRONT.XFE_O.BN.n5 XFRONT.XFE_O.BN.t17 109.174
R5672 XFRONT.XFE_O.BN.n22 XFRONT.XFE_O.BN.n21 18.4942
R5673 XFRONT.XFE_O.BN.n20 XFRONT.XFE_O.BN.n13 18.4942
R5674 XFRONT.XFE_O.BN.n19 XFRONT.XFE_O.BN.n18 18.4942
R5675 XFRONT.XFE_O.BN.n17 XFRONT.XFE_O.BN.n14 18.4942
R5676 XFRONT.XFE_O.BN.n9 XFRONT.XFE_O.BN.n0 18.4942
R5677 XFRONT.XFE_O.BN.n11 XFRONT.XFE_O.BN.n10 18.4942
R5678 XFRONT.XFE_O.BN.n4 XFRONT.XFE_O.BN.n1 18.4942
R5679 XFRONT.XFE_O.BN.n8 XFRONT.XFE_O.BN.n7 18.4942
R5680 XFRONT.XFE_O.BN.n23 XFRONT.XFE_O.BN.n22 15.5414
R5681 XFRONT.XFE_O.BN.n21 XFRONT.XFE_O.BN.n20 11.6805
R5682 XFRONT.XFE_O.BN.n20 XFRONT.XFE_O.BN.n19 11.6805
R5683 XFRONT.XFE_O.BN.n19 XFRONT.XFE_O.BN.n14 11.6805
R5684 XFRONT.XFE_O.BN.n15 XFRONT.XFE_O.BN.n14 11.6805
R5685 XFRONT.XFE_O.BN.n9 XFRONT.XFE_O.BN.n8 11.6805
R5686 XFRONT.XFE_O.BN.n10 XFRONT.XFE_O.BN.n9 11.6805
R5687 XFRONT.XFE_O.BN.n4 XFRONT.XFE_O.BN.n3 11.6805
R5688 XFRONT.XFE_O.BN.n10 XFRONT.XFE_O.BN.n4 11.6805
R5689 XFRONT.XFE_O.BN.n8 XFRONT.XFE_O.BN.n5 11.6805
R5690 XFRONT.XFE_O.BN.n23 XFRONT.XFE_O.BN.n12 9.87478
R5691 XFRONT.XFE_O.BN.n32 XFRONT.XFE_O.BN.n31 8.36407
R5692 XFRONT.XFE_O.BN.n32 XFRONT.XFE_O.BN.n24 7.91407
R5693 XFRONT.XFE_O.BN.n17 XFRONT.XFE_O.BN.n16 7.17687
R5694 XFRONT.XFE_O.BN.n7 XFRONT.XFE_O.BN.n6 7.17687
R5695 XFRONT.XFE_O.BN.n2 XFRONT.XFE_O.BN.n1 7.17687
R5696 XFRONT.XFE_O.BN.n33 XFRONT.XFE_O.BN.n23 6.41789
R5697 XFRONT.XFE_O.BN.n30 XFRONT.XFE_O.BN.t0 5.7796
R5698 XFRONT.XFE_O.BN.n26 XFRONT.XFE_O.BN.t7 5.7796
R5699 XFRONT.XFE_O.BN.n24 XFRONT.XFE_O.BN.t1 5.73764
R5700 XFRONT.XFE_O.BN.n24 XFRONT.XFE_O.BN.t2 5.54817
R5701 XFRONT.XFE_O.BN.n26 XFRONT.XFE_O.BN.n25 5.38537
R5702 XFRONT.XFE_O.BN.n28 XFRONT.XFE_O.BN.n27 5.38537
R5703 XFRONT.XFE_O.BN.n30 XFRONT.XFE_O.BN.n29 5.38537
R5704 XFRONT.XFE_O.BN.n33 XFRONT.XFE_O.BN.n32 4.5005
R5705 XFRONT.XFE_O.BN.n16 XFRONT.XFE_O.BN.n15 4.42851
R5706 XFRONT.XFE_O.BN.n3 XFRONT.XFE_O.BN.n2 4.42851
R5707 XFRONT.XFE_O.BN.n6 XFRONT.XFE_O.BN.n5 4.42851
R5708 XFRONT.XFE_O.BN.n25 XFRONT.XFE_O.BN.t9 0.20525
R5709 XFRONT.XFE_O.BN.n25 XFRONT.XFE_O.BN.t8 0.20525
R5710 XFRONT.XFE_O.BN.n27 XFRONT.XFE_O.BN.t4 0.20525
R5711 XFRONT.XFE_O.BN.n27 XFRONT.XFE_O.BN.t3 0.20525
R5712 XFRONT.XFE_O.BN.n29 XFRONT.XFE_O.BN.t6 0.20525
R5713 XFRONT.XFE_O.BN.n29 XFRONT.XFE_O.BN.t5 0.20525
R5714 XFRONT.XFE_O.BN.n28 XFRONT.XFE_O.BN.n26 0.189974
R5715 XFRONT.XFE_O.BN.n22 XFRONT.XFE_O.BN.n13 0.1205
R5716 XFRONT.XFE_O.BN.n18 XFRONT.XFE_O.BN.n13 0.1205
R5717 XFRONT.XFE_O.BN.n18 XFRONT.XFE_O.BN.n17 0.1205
R5718 XFRONT.XFE_O.BN.n7 XFRONT.XFE_O.BN.n0 0.1205
R5719 XFRONT.XFE_O.BN.n11 XFRONT.XFE_O.BN.n1 0.1205
R5720 XFRONT.XFE_O.BN.n31 XFRONT.XFE_O.BN.n30 0.0952368
R5721 XFRONT.XFE_O.BN.n31 XFRONT.XFE_O.BN.n28 0.0952368
R5722 XFRONT.XFE_O.BN.n12 XFRONT.XFE_O.BN.n0 0.0485
R5723 XFRONT.XFE_O.BN.n12 XFRONT.XFE_O.BN.n11 0.0485
R5724 XFRONT.XFE_O.BN XFRONT.XFE_O.BN.n33 0.0396304
R5725 XFRONT.XFE_O.SXN.n3 XFRONT.XFE_O.SXN.t19 113.632
R5726 XFRONT.XFE_O.SXN.n7 XFRONT.XFE_O.SXN.t12 113.632
R5727 XFRONT.XFE_O.SXN.n0 XFRONT.XFE_O.SXN.t20 113.618
R5728 XFRONT.XFE_O.SXN.n0 XFRONT.XFE_O.SXN.t21 113.618
R5729 XFRONT.XFE_O.SXN.n10 XFRONT.XFE_O.SXN.t15 109.174
R5730 XFRONT.XFE_O.SXN.n11 XFRONT.XFE_O.SXN.t16 109.174
R5731 XFRONT.XFE_O.SXN.n4 XFRONT.XFE_O.SXN.t18 109.174
R5732 XFRONT.XFE_O.SXN.n5 XFRONT.XFE_O.SXN.t17 109.174
R5733 XFRONT.XFE_O.SXN.n9 XFRONT.XFE_O.SXN.t14 109.174
R5734 XFRONT.XFE_O.SXN.n6 XFRONT.XFE_O.SXN.t13 109.174
R5735 XFRONT.XFE_O.SXN.n14 XFRONT.XFE_O.SXN.n0 21.4356
R5736 XFRONT.XFE_O.SXN.n10 XFRONT.XFE_O.SXN.n1 18.4942
R5737 XFRONT.XFE_O.SXN.n12 XFRONT.XFE_O.SXN.n11 18.4942
R5738 XFRONT.XFE_O.SXN.n5 XFRONT.XFE_O.SXN.n2 18.4942
R5739 XFRONT.XFE_O.SXN.n9 XFRONT.XFE_O.SXN.n8 18.4942
R5740 XFRONT.XFE_O.SXN.n26 XFRONT.XFE_O.SXN.n25 17.1983
R5741 XFRONT.XFE_O.SXN.n18 XFRONT.XFE_O.SXN.n17 12.7558
R5742 XFRONT.XFE_O.SXN.n10 XFRONT.XFE_O.SXN.n9 11.6805
R5743 XFRONT.XFE_O.SXN.n11 XFRONT.XFE_O.SXN.n10 11.6805
R5744 XFRONT.XFE_O.SXN.n5 XFRONT.XFE_O.SXN.n4 11.6805
R5745 XFRONT.XFE_O.SXN.n11 XFRONT.XFE_O.SXN.n5 11.6805
R5746 XFRONT.XFE_O.SXN.n9 XFRONT.XFE_O.SXN.n6 11.6805
R5747 XFRONT.XFE_O.SXN.n18 XFRONT.XFE_O.SXN.n14 11.3092
R5748 XFRONT.XFE_O.SXN.n14 XFRONT.XFE_O.SXN.n13 10.9034
R5749 XFRONT.XFE_O.SXN.n8 XFRONT.XFE_O.SXN.n7 7.17687
R5750 XFRONT.XFE_O.SXN.n3 XFRONT.XFE_O.SXN.n2 7.17687
R5751 XFRONT.XFE_O.SXN.n16 XFRONT.XFE_O.SXN.t11 5.7796
R5752 XFRONT.XFE_O.SXN.n20 XFRONT.XFE_O.SXN.t2 5.73764
R5753 XFRONT.XFE_O.SXN.n17 XFRONT.XFE_O.SXN.t0 5.59012
R5754 XFRONT.XFE_O.SXN.n25 XFRONT.XFE_O.SXN.t3 5.54817
R5755 XFRONT.XFE_O.SXN.n16 XFRONT.XFE_O.SXN.n15 5.38537
R5756 XFRONT.XFE_O.SXN.n24 XFRONT.XFE_O.SXN.n23 5.32067
R5757 XFRONT.XFE_O.SXN.n22 XFRONT.XFE_O.SXN.n21 5.32067
R5758 XFRONT.XFE_O.SXN.n20 XFRONT.XFE_O.SXN.n19 5.32067
R5759 XFRONT.XFE_O.SXN.n4 XFRONT.XFE_O.SXN.n3 4.42851
R5760 XFRONT.XFE_O.SXN.n7 XFRONT.XFE_O.SXN.n6 4.42851
R5761 XFRONT.XFE_O.SXN.n26 XFRONT.XFE_O.SXN.n18 0.313543
R5762 XFRONT.XFE_O.SXN.n23 XFRONT.XFE_O.SXN.t5 0.228
R5763 XFRONT.XFE_O.SXN.n23 XFRONT.XFE_O.SXN.t4 0.228
R5764 XFRONT.XFE_O.SXN.n21 XFRONT.XFE_O.SXN.t7 0.228
R5765 XFRONT.XFE_O.SXN.n21 XFRONT.XFE_O.SXN.t6 0.228
R5766 XFRONT.XFE_O.SXN.n19 XFRONT.XFE_O.SXN.t1 0.228
R5767 XFRONT.XFE_O.SXN.n19 XFRONT.XFE_O.SXN.t8 0.228
R5768 XFRONT.XFE_O.SXN.n15 XFRONT.XFE_O.SXN.t10 0.20525
R5769 XFRONT.XFE_O.SXN.n15 XFRONT.XFE_O.SXN.t9 0.20525
R5770 XFRONT.XFE_O.SXN.n17 XFRONT.XFE_O.SXN.n16 0.189974
R5771 XFRONT.XFE_O.SXN.n22 XFRONT.XFE_O.SXN.n20 0.189974
R5772 XFRONT.XFE_O.SXN.n24 XFRONT.XFE_O.SXN.n22 0.189974
R5773 XFRONT.XFE_O.SXN.n25 XFRONT.XFE_O.SXN.n24 0.189974
R5774 XFRONT.XFE_O.SXN.n8 XFRONT.XFE_O.SXN.n1 0.1205
R5775 XFRONT.XFE_O.SXN.n12 XFRONT.XFE_O.SXN.n2 0.1205
R5776 XFRONT.XFE_O.SXN.n13 XFRONT.XFE_O.SXN.n1 0.0485
R5777 XFRONT.XFE_O.SXN.n13 XFRONT.XFE_O.SXN.n12 0.0485
R5778 XFRONT.XFE_O.SXN XFRONT.XFE_O.SXN.n26 0.0396304
R5779 XFRONT.XFE_O.SXP.n14 XFRONT.XFE_O.SXP.t19 113.632
R5780 XFRONT.XFE_O.SXP.n18 XFRONT.XFE_O.SXP.t12 113.632
R5781 XFRONT.XFE_O.SXP.n11 XFRONT.XFE_O.SXP.t20 113.618
R5782 XFRONT.XFE_O.SXP.n11 XFRONT.XFE_O.SXP.t21 113.618
R5783 XFRONT.XFE_O.SXP.n21 XFRONT.XFE_O.SXP.t15 109.174
R5784 XFRONT.XFE_O.SXP.n22 XFRONT.XFE_O.SXP.t16 109.174
R5785 XFRONT.XFE_O.SXP.n15 XFRONT.XFE_O.SXP.t18 109.174
R5786 XFRONT.XFE_O.SXP.n16 XFRONT.XFE_O.SXP.t17 109.174
R5787 XFRONT.XFE_O.SXP.n20 XFRONT.XFE_O.SXP.t14 109.174
R5788 XFRONT.XFE_O.SXP.n17 XFRONT.XFE_O.SXP.t13 109.174
R5789 XFRONT.XFE_O.SXP.n25 XFRONT.XFE_O.SXP.n11 21.8856
R5790 XFRONT.XFE_O.SXP.n21 XFRONT.XFE_O.SXP.n12 18.4942
R5791 XFRONT.XFE_O.SXP.n23 XFRONT.XFE_O.SXP.n22 18.4942
R5792 XFRONT.XFE_O.SXP.n16 XFRONT.XFE_O.SXP.n13 18.4942
R5793 XFRONT.XFE_O.SXP.n20 XFRONT.XFE_O.SXP.n19 18.4942
R5794 XFRONT.XFE_O.SXP.n26 XFRONT.XFE_O.SXP.n10 15.1644
R5795 XFRONT.XFE_O.SXP.n21 XFRONT.XFE_O.SXP.n20 11.6805
R5796 XFRONT.XFE_O.SXP.n22 XFRONT.XFE_O.SXP.n21 11.6805
R5797 XFRONT.XFE_O.SXP.n16 XFRONT.XFE_O.SXP.n15 11.6805
R5798 XFRONT.XFE_O.SXP.n22 XFRONT.XFE_O.SXP.n16 11.6805
R5799 XFRONT.XFE_O.SXP.n20 XFRONT.XFE_O.SXP.n17 11.6805
R5800 XFRONT.XFE_O.SXP.n25 XFRONT.XFE_O.SXP.n24 10.4534
R5801 XFRONT.XFE_O.SXP.n10 XFRONT.XFE_O.SXP.n6 9.54828
R5802 XFRONT.XFE_O.SXP.n19 XFRONT.XFE_O.SXP.n18 7.17687
R5803 XFRONT.XFE_O.SXP.n14 XFRONT.XFE_O.SXP.n13 7.17687
R5804 XFRONT.XFE_O.SXP.n8 XFRONT.XFE_O.SXP.t6 5.7796
R5805 XFRONT.XFE_O.SXP.n1 XFRONT.XFE_O.SXP.t4 5.73764
R5806 XFRONT.XFE_O.SXP.n9 XFRONT.XFE_O.SXP.t9 5.59012
R5807 XFRONT.XFE_O.SXP.n6 XFRONT.XFE_O.SXP.t3 5.54817
R5808 XFRONT.XFE_O.SXP.n8 XFRONT.XFE_O.SXP.n7 5.38537
R5809 XFRONT.XFE_O.SXP.n3 XFRONT.XFE_O.SXP.n2 5.32067
R5810 XFRONT.XFE_O.SXP.n1 XFRONT.XFE_O.SXP.n0 5.32067
R5811 XFRONT.XFE_O.SXP.n5 XFRONT.XFE_O.SXP.n4 5.32067
R5812 XFRONT.XFE_O.SXP.n10 XFRONT.XFE_O.SXP.n9 4.97418
R5813 XFRONT.XFE_O.SXP.n26 XFRONT.XFE_O.SXP.n25 4.5005
R5814 XFRONT.XFE_O.SXP.n15 XFRONT.XFE_O.SXP.n14 4.42851
R5815 XFRONT.XFE_O.SXP.n18 XFRONT.XFE_O.SXP.n17 4.42851
R5816 XFRONT.XFE_O.SXP.n2 XFRONT.XFE_O.SXP.t0 0.228
R5817 XFRONT.XFE_O.SXP.n2 XFRONT.XFE_O.SXP.t11 0.228
R5818 XFRONT.XFE_O.SXP.n0 XFRONT.XFE_O.SXP.t10 0.228
R5819 XFRONT.XFE_O.SXP.n0 XFRONT.XFE_O.SXP.t5 0.228
R5820 XFRONT.XFE_O.SXP.n4 XFRONT.XFE_O.SXP.t2 0.228
R5821 XFRONT.XFE_O.SXP.n4 XFRONT.XFE_O.SXP.t1 0.228
R5822 XFRONT.XFE_O.SXP.n7 XFRONT.XFE_O.SXP.t8 0.20525
R5823 XFRONT.XFE_O.SXP.n7 XFRONT.XFE_O.SXP.t7 0.20525
R5824 XFRONT.XFE_O.SXP.n6 XFRONT.XFE_O.SXP.n5 0.189974
R5825 XFRONT.XFE_O.SXP.n5 XFRONT.XFE_O.SXP.n3 0.189974
R5826 XFRONT.XFE_O.SXP.n3 XFRONT.XFE_O.SXP.n1 0.189974
R5827 XFRONT.XFE_O.SXP.n9 XFRONT.XFE_O.SXP.n8 0.189974
R5828 XFRONT.XFE_O.SXP.n19 XFRONT.XFE_O.SXP.n12 0.1205
R5829 XFRONT.XFE_O.SXP.n23 XFRONT.XFE_O.SXP.n13 0.1205
R5830 XFRONT.XFE_O.SXP.n24 XFRONT.XFE_O.SXP.n12 0.0485
R5831 XFRONT.XFE_O.SXP.n24 XFRONT.XFE_O.SXP.n23 0.0485
R5832 XFRONT.XFE_O.SXP XFRONT.XFE_O.SXP.n26 0.0396304
R5833 XFRONT.XFE_O.BP.n25 XFRONT.XFE_O.BP.t15 113.632
R5834 XFRONT.XFE_O.BP.n11 XFRONT.XFE_O.BP.t23 113.632
R5835 XFRONT.XFE_O.BP.n15 XFRONT.XFE_O.BP.t16 113.632
R5836 XFRONT.XFE_O.BP.n26 XFRONT.XFE_O.BP.t14 109.174
R5837 XFRONT.XFE_O.BP.n27 XFRONT.XFE_O.BP.t13 109.174
R5838 XFRONT.XFE_O.BP.n28 XFRONT.XFE_O.BP.t12 109.174
R5839 XFRONT.XFE_O.BP.n29 XFRONT.XFE_O.BP.t11 109.174
R5840 XFRONT.XFE_O.BP.n30 XFRONT.XFE_O.BP.t10 109.174
R5841 XFRONT.XFE_O.BP.n18 XFRONT.XFE_O.BP.t19 109.174
R5842 XFRONT.XFE_O.BP.n19 XFRONT.XFE_O.BP.t20 109.174
R5843 XFRONT.XFE_O.BP.n12 XFRONT.XFE_O.BP.t22 109.174
R5844 XFRONT.XFE_O.BP.n13 XFRONT.XFE_O.BP.t21 109.174
R5845 XFRONT.XFE_O.BP.n17 XFRONT.XFE_O.BP.t18 109.174
R5846 XFRONT.XFE_O.BP.n14 XFRONT.XFE_O.BP.t17 109.174
R5847 XFRONT.XFE_O.BP.n27 XFRONT.XFE_O.BP.n24 18.4942
R5848 XFRONT.XFE_O.BP.n28 XFRONT.XFE_O.BP.n23 18.4942
R5849 XFRONT.XFE_O.BP.n29 XFRONT.XFE_O.BP.n22 18.4942
R5850 XFRONT.XFE_O.BP.n31 XFRONT.XFE_O.BP.n30 18.4942
R5851 XFRONT.XFE_O.BP.n18 XFRONT.XFE_O.BP.n9 18.4942
R5852 XFRONT.XFE_O.BP.n20 XFRONT.XFE_O.BP.n19 18.4942
R5853 XFRONT.XFE_O.BP.n13 XFRONT.XFE_O.BP.n10 18.4942
R5854 XFRONT.XFE_O.BP.n17 XFRONT.XFE_O.BP.n16 18.4942
R5855 XFRONT.XFE_O.BP.n32 XFRONT.XFE_O.BP.n31 15.0914
R5856 XFRONT.XFE_O.BP.n27 XFRONT.XFE_O.BP.n26 11.6805
R5857 XFRONT.XFE_O.BP.n28 XFRONT.XFE_O.BP.n27 11.6805
R5858 XFRONT.XFE_O.BP.n29 XFRONT.XFE_O.BP.n28 11.6805
R5859 XFRONT.XFE_O.BP.n30 XFRONT.XFE_O.BP.n29 11.6805
R5860 XFRONT.XFE_O.BP.n18 XFRONT.XFE_O.BP.n17 11.6805
R5861 XFRONT.XFE_O.BP.n19 XFRONT.XFE_O.BP.n18 11.6805
R5862 XFRONT.XFE_O.BP.n13 XFRONT.XFE_O.BP.n12 11.6805
R5863 XFRONT.XFE_O.BP.n19 XFRONT.XFE_O.BP.n13 11.6805
R5864 XFRONT.XFE_O.BP.n17 XFRONT.XFE_O.BP.n14 11.6805
R5865 XFRONT.XFE_O.BP.n32 XFRONT.XFE_O.BP.n21 10.3248
R5866 XFRONT.XFE_O.BP.n8 XFRONT.XFE_O.BP.n0 8.36407
R5867 XFRONT.XFE_O.BP.n8 XFRONT.XFE_O.BP.n7 7.91407
R5868 XFRONT.XFE_O.BP.n25 XFRONT.XFE_O.BP.n24 7.17687
R5869 XFRONT.XFE_O.BP.n16 XFRONT.XFE_O.BP.n15 7.17687
R5870 XFRONT.XFE_O.BP.n11 XFRONT.XFE_O.BP.n10 7.17687
R5871 XFRONT.XFE_O.BP.n33 XFRONT.XFE_O.BP.n8 6.10485
R5872 XFRONT.XFE_O.BP.n2 XFRONT.XFE_O.BP.t9 5.7796
R5873 XFRONT.XFE_O.BP.n6 XFRONT.XFE_O.BP.t2 5.7796
R5874 XFRONT.XFE_O.BP.n0 XFRONT.XFE_O.BP.t1 5.73764
R5875 XFRONT.XFE_O.BP.n0 XFRONT.XFE_O.BP.t0 5.54817
R5876 XFRONT.XFE_O.BP.n2 XFRONT.XFE_O.BP.n1 5.38537
R5877 XFRONT.XFE_O.BP.n4 XFRONT.XFE_O.BP.n3 5.38537
R5878 XFRONT.XFE_O.BP.n6 XFRONT.XFE_O.BP.n5 5.38537
R5879 XFRONT.XFE_O.BP.n33 XFRONT.XFE_O.BP.n32 4.5005
R5880 XFRONT.XFE_O.BP.n26 XFRONT.XFE_O.BP.n25 4.42851
R5881 XFRONT.XFE_O.BP.n12 XFRONT.XFE_O.BP.n11 4.42851
R5882 XFRONT.XFE_O.BP.n15 XFRONT.XFE_O.BP.n14 4.42851
R5883 XFRONT.XFE_O.BP.n1 XFRONT.XFE_O.BP.t7 0.20525
R5884 XFRONT.XFE_O.BP.n1 XFRONT.XFE_O.BP.t8 0.20525
R5885 XFRONT.XFE_O.BP.n3 XFRONT.XFE_O.BP.t5 0.20525
R5886 XFRONT.XFE_O.BP.n3 XFRONT.XFE_O.BP.t6 0.20525
R5887 XFRONT.XFE_O.BP.n5 XFRONT.XFE_O.BP.t3 0.20525
R5888 XFRONT.XFE_O.BP.n5 XFRONT.XFE_O.BP.t4 0.20525
R5889 XFRONT.XFE_O.BP.n4 XFRONT.XFE_O.BP.n2 0.189974
R5890 XFRONT.XFE_O.BP.n24 XFRONT.XFE_O.BP.n23 0.1205
R5891 XFRONT.XFE_O.BP.n23 XFRONT.XFE_O.BP.n22 0.1205
R5892 XFRONT.XFE_O.BP.n31 XFRONT.XFE_O.BP.n22 0.1205
R5893 XFRONT.XFE_O.BP.n16 XFRONT.XFE_O.BP.n9 0.1205
R5894 XFRONT.XFE_O.BP.n20 XFRONT.XFE_O.BP.n10 0.1205
R5895 XFRONT.XFE_O.BP.n7 XFRONT.XFE_O.BP.n6 0.0952368
R5896 XFRONT.XFE_O.BP.n7 XFRONT.XFE_O.BP.n4 0.0952368
R5897 XFRONT.XFE_O.BP.n21 XFRONT.XFE_O.BP.n9 0.0485
R5898 XFRONT.XFE_O.BP.n21 XFRONT.XFE_O.BP.n20 0.0485
R5899 XFRONT.XFE_O.BP XFRONT.XFE_O.BP.n33 0.0396304
R5900 XFRONT.XFE_E.BP.n16 XFRONT.XFE_E.BP.t10 113.632
R5901 XFRONT.XFE_E.BP.n2 XFRONT.XFE_E.BP.t23 113.632
R5902 XFRONT.XFE_E.BP.n6 XFRONT.XFE_E.BP.t16 113.632
R5903 XFRONT.XFE_E.BP.n21 XFRONT.XFE_E.BP.t15 109.174
R5904 XFRONT.XFE_E.BP.n20 XFRONT.XFE_E.BP.t14 109.174
R5905 XFRONT.XFE_E.BP.n19 XFRONT.XFE_E.BP.t13 109.174
R5906 XFRONT.XFE_E.BP.n14 XFRONT.XFE_E.BP.t12 109.174
R5907 XFRONT.XFE_E.BP.n15 XFRONT.XFE_E.BP.t11 109.174
R5908 XFRONT.XFE_E.BP.n9 XFRONT.XFE_E.BP.t19 109.174
R5909 XFRONT.XFE_E.BP.n10 XFRONT.XFE_E.BP.t20 109.174
R5910 XFRONT.XFE_E.BP.n3 XFRONT.XFE_E.BP.t22 109.174
R5911 XFRONT.XFE_E.BP.n4 XFRONT.XFE_E.BP.t21 109.174
R5912 XFRONT.XFE_E.BP.n8 XFRONT.XFE_E.BP.t18 109.174
R5913 XFRONT.XFE_E.BP.n5 XFRONT.XFE_E.BP.t17 109.174
R5914 XFRONT.XFE_E.BP.n22 XFRONT.XFE_E.BP.n21 18.4942
R5915 XFRONT.XFE_E.BP.n20 XFRONT.XFE_E.BP.n13 18.4942
R5916 XFRONT.XFE_E.BP.n19 XFRONT.XFE_E.BP.n18 18.4942
R5917 XFRONT.XFE_E.BP.n17 XFRONT.XFE_E.BP.n14 18.4942
R5918 XFRONT.XFE_E.BP.n9 XFRONT.XFE_E.BP.n0 18.4942
R5919 XFRONT.XFE_E.BP.n11 XFRONT.XFE_E.BP.n10 18.4942
R5920 XFRONT.XFE_E.BP.n4 XFRONT.XFE_E.BP.n1 18.4942
R5921 XFRONT.XFE_E.BP.n8 XFRONT.XFE_E.BP.n7 18.4942
R5922 XFRONT.XFE_E.BP.n23 XFRONT.XFE_E.BP.n22 15.0914
R5923 XFRONT.XFE_E.BP.n21 XFRONT.XFE_E.BP.n20 11.6805
R5924 XFRONT.XFE_E.BP.n20 XFRONT.XFE_E.BP.n19 11.6805
R5925 XFRONT.XFE_E.BP.n19 XFRONT.XFE_E.BP.n14 11.6805
R5926 XFRONT.XFE_E.BP.n15 XFRONT.XFE_E.BP.n14 11.6805
R5927 XFRONT.XFE_E.BP.n9 XFRONT.XFE_E.BP.n8 11.6805
R5928 XFRONT.XFE_E.BP.n10 XFRONT.XFE_E.BP.n9 11.6805
R5929 XFRONT.XFE_E.BP.n4 XFRONT.XFE_E.BP.n3 11.6805
R5930 XFRONT.XFE_E.BP.n10 XFRONT.XFE_E.BP.n4 11.6805
R5931 XFRONT.XFE_E.BP.n8 XFRONT.XFE_E.BP.n5 11.6805
R5932 XFRONT.XFE_E.BP.n23 XFRONT.XFE_E.BP.n12 10.3248
R5933 XFRONT.XFE_E.BP.n32 XFRONT.XFE_E.BP.n24 8.36407
R5934 XFRONT.XFE_E.BP.n32 XFRONT.XFE_E.BP.n31 7.91407
R5935 XFRONT.XFE_E.BP.n17 XFRONT.XFE_E.BP.n16 7.17687
R5936 XFRONT.XFE_E.BP.n7 XFRONT.XFE_E.BP.n6 7.17687
R5937 XFRONT.XFE_E.BP.n2 XFRONT.XFE_E.BP.n1 7.17687
R5938 XFRONT.XFE_E.BP XFRONT.XFE_E.BP.n32 6.06572
R5939 XFRONT.XFE_E.BP.n26 XFRONT.XFE_E.BP.t0 5.7796
R5940 XFRONT.XFE_E.BP.n28 XFRONT.XFE_E.BP.t7 5.7796
R5941 XFRONT.XFE_E.BP.n24 XFRONT.XFE_E.BP.t9 5.73764
R5942 XFRONT.XFE_E.BP.n24 XFRONT.XFE_E.BP.t8 5.54817
R5943 XFRONT.XFE_E.BP.n26 XFRONT.XFE_E.BP.n25 5.38537
R5944 XFRONT.XFE_E.BP.n30 XFRONT.XFE_E.BP.n29 5.38537
R5945 XFRONT.XFE_E.BP.n28 XFRONT.XFE_E.BP.n27 5.38537
R5946 XFRONT.XFE_E.BP XFRONT.XFE_E.BP.n23 4.53963
R5947 XFRONT.XFE_E.BP.n16 XFRONT.XFE_E.BP.n15 4.42851
R5948 XFRONT.XFE_E.BP.n3 XFRONT.XFE_E.BP.n2 4.42851
R5949 XFRONT.XFE_E.BP.n6 XFRONT.XFE_E.BP.n5 4.42851
R5950 XFRONT.XFE_E.BP.n25 XFRONT.XFE_E.BP.t2 0.20525
R5951 XFRONT.XFE_E.BP.n25 XFRONT.XFE_E.BP.t1 0.20525
R5952 XFRONT.XFE_E.BP.n29 XFRONT.XFE_E.BP.t4 0.20525
R5953 XFRONT.XFE_E.BP.n29 XFRONT.XFE_E.BP.t3 0.20525
R5954 XFRONT.XFE_E.BP.n27 XFRONT.XFE_E.BP.t6 0.20525
R5955 XFRONT.XFE_E.BP.n27 XFRONT.XFE_E.BP.t5 0.20525
R5956 XFRONT.XFE_E.BP.n30 XFRONT.XFE_E.BP.n28 0.189974
R5957 XFRONT.XFE_E.BP.n22 XFRONT.XFE_E.BP.n13 0.1205
R5958 XFRONT.XFE_E.BP.n18 XFRONT.XFE_E.BP.n13 0.1205
R5959 XFRONT.XFE_E.BP.n18 XFRONT.XFE_E.BP.n17 0.1205
R5960 XFRONT.XFE_E.BP.n7 XFRONT.XFE_E.BP.n0 0.1205
R5961 XFRONT.XFE_E.BP.n11 XFRONT.XFE_E.BP.n1 0.1205
R5962 XFRONT.XFE_E.BP.n31 XFRONT.XFE_E.BP.n30 0.0952368
R5963 XFRONT.XFE_E.BP.n31 XFRONT.XFE_E.BP.n26 0.0952368
R5964 XFRONT.XFE_E.BP.n12 XFRONT.XFE_E.BP.n0 0.0485
R5965 XFRONT.XFE_E.BP.n12 XFRONT.XFE_E.BP.n11 0.0485
R5966 XFRONT.XFE_E.SXP.n3 XFRONT.XFE_E.SXP.t19 113.632
R5967 XFRONT.XFE_E.SXP.n7 XFRONT.XFE_E.SXP.t12 113.632
R5968 XFRONT.XFE_E.SXP.n0 XFRONT.XFE_E.SXP.t20 113.618
R5969 XFRONT.XFE_E.SXP.n0 XFRONT.XFE_E.SXP.t21 113.618
R5970 XFRONT.XFE_E.SXP.n10 XFRONT.XFE_E.SXP.t15 109.174
R5971 XFRONT.XFE_E.SXP.n11 XFRONT.XFE_E.SXP.t16 109.174
R5972 XFRONT.XFE_E.SXP.n4 XFRONT.XFE_E.SXP.t18 109.174
R5973 XFRONT.XFE_E.SXP.n5 XFRONT.XFE_E.SXP.t17 109.174
R5974 XFRONT.XFE_E.SXP.n9 XFRONT.XFE_E.SXP.t14 109.174
R5975 XFRONT.XFE_E.SXP.n6 XFRONT.XFE_E.SXP.t13 109.174
R5976 XFRONT.XFE_E.SXP.n14 XFRONT.XFE_E.SXP.n0 21.8856
R5977 XFRONT.XFE_E.SXP.n10 XFRONT.XFE_E.SXP.n1 18.4942
R5978 XFRONT.XFE_E.SXP.n12 XFRONT.XFE_E.SXP.n11 18.4942
R5979 XFRONT.XFE_E.SXP.n5 XFRONT.XFE_E.SXP.n2 18.4942
R5980 XFRONT.XFE_E.SXP.n9 XFRONT.XFE_E.SXP.n8 18.4942
R5981 XFRONT.XFE_E.SXP XFRONT.XFE_E.SXP.n25 15.1253
R5982 XFRONT.XFE_E.SXP.n10 XFRONT.XFE_E.SXP.n9 11.6805
R5983 XFRONT.XFE_E.SXP.n11 XFRONT.XFE_E.SXP.n10 11.6805
R5984 XFRONT.XFE_E.SXP.n5 XFRONT.XFE_E.SXP.n4 11.6805
R5985 XFRONT.XFE_E.SXP.n11 XFRONT.XFE_E.SXP.n5 11.6805
R5986 XFRONT.XFE_E.SXP.n9 XFRONT.XFE_E.SXP.n6 11.6805
R5987 XFRONT.XFE_E.SXP.n14 XFRONT.XFE_E.SXP.n13 10.4534
R5988 XFRONT.XFE_E.SXP.n25 XFRONT.XFE_E.SXP.n21 9.54828
R5989 XFRONT.XFE_E.SXP.n8 XFRONT.XFE_E.SXP.n7 7.17687
R5990 XFRONT.XFE_E.SXP.n3 XFRONT.XFE_E.SXP.n2 7.17687
R5991 XFRONT.XFE_E.SXP.n23 XFRONT.XFE_E.SXP.t8 5.7796
R5992 XFRONT.XFE_E.SXP.n16 XFRONT.XFE_E.SXP.t1 5.73764
R5993 XFRONT.XFE_E.SXP.n24 XFRONT.XFE_E.SXP.t5 5.59012
R5994 XFRONT.XFE_E.SXP.n21 XFRONT.XFE_E.SXP.t2 5.54817
R5995 XFRONT.XFE_E.SXP.n23 XFRONT.XFE_E.SXP.n22 5.38537
R5996 XFRONT.XFE_E.SXP.n16 XFRONT.XFE_E.SXP.n15 5.32067
R5997 XFRONT.XFE_E.SXP.n20 XFRONT.XFE_E.SXP.n19 5.32067
R5998 XFRONT.XFE_E.SXP.n18 XFRONT.XFE_E.SXP.n17 5.32067
R5999 XFRONT.XFE_E.SXP.n25 XFRONT.XFE_E.SXP.n24 4.97418
R6000 XFRONT.XFE_E.SXP XFRONT.XFE_E.SXP.n14 4.53963
R6001 XFRONT.XFE_E.SXP.n4 XFRONT.XFE_E.SXP.n3 4.42851
R6002 XFRONT.XFE_E.SXP.n7 XFRONT.XFE_E.SXP.n6 4.42851
R6003 XFRONT.XFE_E.SXP.n15 XFRONT.XFE_E.SXP.t0 0.228
R6004 XFRONT.XFE_E.SXP.n15 XFRONT.XFE_E.SXP.t11 0.228
R6005 XFRONT.XFE_E.SXP.n19 XFRONT.XFE_E.SXP.t4 0.228
R6006 XFRONT.XFE_E.SXP.n19 XFRONT.XFE_E.SXP.t3 0.228
R6007 XFRONT.XFE_E.SXP.n17 XFRONT.XFE_E.SXP.t10 0.228
R6008 XFRONT.XFE_E.SXP.n17 XFRONT.XFE_E.SXP.t9 0.228
R6009 XFRONT.XFE_E.SXP.n22 XFRONT.XFE_E.SXP.t7 0.20525
R6010 XFRONT.XFE_E.SXP.n22 XFRONT.XFE_E.SXP.t6 0.20525
R6011 XFRONT.XFE_E.SXP.n18 XFRONT.XFE_E.SXP.n16 0.189974
R6012 XFRONT.XFE_E.SXP.n20 XFRONT.XFE_E.SXP.n18 0.189974
R6013 XFRONT.XFE_E.SXP.n21 XFRONT.XFE_E.SXP.n20 0.189974
R6014 XFRONT.XFE_E.SXP.n24 XFRONT.XFE_E.SXP.n23 0.189974
R6015 XFRONT.XFE_E.SXP.n8 XFRONT.XFE_E.SXP.n1 0.1205
R6016 XFRONT.XFE_E.SXP.n12 XFRONT.XFE_E.SXP.n2 0.1205
R6017 XFRONT.XFE_E.SXP.n13 XFRONT.XFE_E.SXP.n1 0.0485
R6018 XFRONT.XFE_E.SXP.n13 XFRONT.XFE_E.SXP.n12 0.0485
R6019 XFRONT.XFE_E.SXN.n10 XFRONT.XFE_E.SXN.t19 113.632
R6020 XFRONT.XFE_E.SXN.n14 XFRONT.XFE_E.SXN.t12 113.632
R6021 XFRONT.XFE_E.SXN.n7 XFRONT.XFE_E.SXN.t20 113.618
R6022 XFRONT.XFE_E.SXN.n7 XFRONT.XFE_E.SXN.t21 113.618
R6023 XFRONT.XFE_E.SXN.n17 XFRONT.XFE_E.SXN.t15 109.174
R6024 XFRONT.XFE_E.SXN.n18 XFRONT.XFE_E.SXN.t16 109.174
R6025 XFRONT.XFE_E.SXN.n11 XFRONT.XFE_E.SXN.t18 109.174
R6026 XFRONT.XFE_E.SXN.n12 XFRONT.XFE_E.SXN.t17 109.174
R6027 XFRONT.XFE_E.SXN.n16 XFRONT.XFE_E.SXN.t14 109.174
R6028 XFRONT.XFE_E.SXN.n13 XFRONT.XFE_E.SXN.t13 109.174
R6029 XFRONT.XFE_E.SXN.n21 XFRONT.XFE_E.SXN.n7 21.4356
R6030 XFRONT.XFE_E.SXN.n17 XFRONT.XFE_E.SXN.n8 18.4942
R6031 XFRONT.XFE_E.SXN.n19 XFRONT.XFE_E.SXN.n18 18.4942
R6032 XFRONT.XFE_E.SXN.n12 XFRONT.XFE_E.SXN.n9 18.4942
R6033 XFRONT.XFE_E.SXN.n16 XFRONT.XFE_E.SXN.n15 18.4942
R6034 XFRONT.XFE_E.SXN XFRONT.XFE_E.SXN.n6 17.2374
R6035 XFRONT.XFE_E.SXN.n25 XFRONT.XFE_E.SXN.n24 12.7558
R6036 XFRONT.XFE_E.SXN.n17 XFRONT.XFE_E.SXN.n16 11.6805
R6037 XFRONT.XFE_E.SXN.n18 XFRONT.XFE_E.SXN.n17 11.6805
R6038 XFRONT.XFE_E.SXN.n12 XFRONT.XFE_E.SXN.n11 11.6805
R6039 XFRONT.XFE_E.SXN.n18 XFRONT.XFE_E.SXN.n12 11.6805
R6040 XFRONT.XFE_E.SXN.n16 XFRONT.XFE_E.SXN.n13 11.6805
R6041 XFRONT.XFE_E.SXN.n25 XFRONT.XFE_E.SXN.n21 11.3092
R6042 XFRONT.XFE_E.SXN.n21 XFRONT.XFE_E.SXN.n20 10.9034
R6043 XFRONT.XFE_E.SXN.n15 XFRONT.XFE_E.SXN.n14 7.17687
R6044 XFRONT.XFE_E.SXN.n10 XFRONT.XFE_E.SXN.n9 7.17687
R6045 XFRONT.XFE_E.SXN.n23 XFRONT.XFE_E.SXN.t7 5.7796
R6046 XFRONT.XFE_E.SXN.n1 XFRONT.XFE_E.SXN.t5 5.73764
R6047 XFRONT.XFE_E.SXN.n24 XFRONT.XFE_E.SXN.t2 5.59012
R6048 XFRONT.XFE_E.SXN.n6 XFRONT.XFE_E.SXN.t9 5.54817
R6049 XFRONT.XFE_E.SXN.n23 XFRONT.XFE_E.SXN.n22 5.38537
R6050 XFRONT.XFE_E.SXN.n1 XFRONT.XFE_E.SXN.n0 5.32067
R6051 XFRONT.XFE_E.SXN.n3 XFRONT.XFE_E.SXN.n2 5.32067
R6052 XFRONT.XFE_E.SXN.n5 XFRONT.XFE_E.SXN.n4 5.32067
R6053 XFRONT.XFE_E.SXN.n11 XFRONT.XFE_E.SXN.n10 4.42851
R6054 XFRONT.XFE_E.SXN.n14 XFRONT.XFE_E.SXN.n13 4.42851
R6055 XFRONT.XFE_E.SXN XFRONT.XFE_E.SXN.n25 0.274413
R6056 XFRONT.XFE_E.SXN.n0 XFRONT.XFE_E.SXN.t3 0.228
R6057 XFRONT.XFE_E.SXN.n0 XFRONT.XFE_E.SXN.t6 0.228
R6058 XFRONT.XFE_E.SXN.n2 XFRONT.XFE_E.SXN.t10 0.228
R6059 XFRONT.XFE_E.SXN.n2 XFRONT.XFE_E.SXN.t4 0.228
R6060 XFRONT.XFE_E.SXN.n4 XFRONT.XFE_E.SXN.t8 0.228
R6061 XFRONT.XFE_E.SXN.n4 XFRONT.XFE_E.SXN.t11 0.228
R6062 XFRONT.XFE_E.SXN.n22 XFRONT.XFE_E.SXN.t1 0.20525
R6063 XFRONT.XFE_E.SXN.n22 XFRONT.XFE_E.SXN.t0 0.20525
R6064 XFRONT.XFE_E.SXN.n24 XFRONT.XFE_E.SXN.n23 0.189974
R6065 XFRONT.XFE_E.SXN.n6 XFRONT.XFE_E.SXN.n5 0.189974
R6066 XFRONT.XFE_E.SXN.n5 XFRONT.XFE_E.SXN.n3 0.189974
R6067 XFRONT.XFE_E.SXN.n3 XFRONT.XFE_E.SXN.n1 0.189974
R6068 XFRONT.XFE_E.SXN.n15 XFRONT.XFE_E.SXN.n8 0.1205
R6069 XFRONT.XFE_E.SXN.n19 XFRONT.XFE_E.SXN.n9 0.1205
R6070 XFRONT.XFE_E.SXN.n20 XFRONT.XFE_E.SXN.n8 0.0485
R6071 XFRONT.XFE_E.SXN.n20 XFRONT.XFE_E.SXN.n19 0.0485
R6072 XFRONT.XFE_E.BN.n25 XFRONT.XFE_E.BN.t15 113.632
R6073 XFRONT.XFE_E.BN.n11 XFRONT.XFE_E.BN.t23 113.632
R6074 XFRONT.XFE_E.BN.n15 XFRONT.XFE_E.BN.t16 113.632
R6075 XFRONT.XFE_E.BN.n26 XFRONT.XFE_E.BN.t14 109.174
R6076 XFRONT.XFE_E.BN.n27 XFRONT.XFE_E.BN.t13 109.174
R6077 XFRONT.XFE_E.BN.n28 XFRONT.XFE_E.BN.t12 109.174
R6078 XFRONT.XFE_E.BN.n29 XFRONT.XFE_E.BN.t11 109.174
R6079 XFRONT.XFE_E.BN.n30 XFRONT.XFE_E.BN.t10 109.174
R6080 XFRONT.XFE_E.BN.n18 XFRONT.XFE_E.BN.t19 109.174
R6081 XFRONT.XFE_E.BN.n19 XFRONT.XFE_E.BN.t20 109.174
R6082 XFRONT.XFE_E.BN.n12 XFRONT.XFE_E.BN.t22 109.174
R6083 XFRONT.XFE_E.BN.n13 XFRONT.XFE_E.BN.t21 109.174
R6084 XFRONT.XFE_E.BN.n17 XFRONT.XFE_E.BN.t18 109.174
R6085 XFRONT.XFE_E.BN.n14 XFRONT.XFE_E.BN.t17 109.174
R6086 XFRONT.XFE_E.BN.n27 XFRONT.XFE_E.BN.n24 18.4942
R6087 XFRONT.XFE_E.BN.n28 XFRONT.XFE_E.BN.n23 18.4942
R6088 XFRONT.XFE_E.BN.n29 XFRONT.XFE_E.BN.n22 18.4942
R6089 XFRONT.XFE_E.BN.n31 XFRONT.XFE_E.BN.n30 18.4942
R6090 XFRONT.XFE_E.BN.n18 XFRONT.XFE_E.BN.n9 18.4942
R6091 XFRONT.XFE_E.BN.n20 XFRONT.XFE_E.BN.n19 18.4942
R6092 XFRONT.XFE_E.BN.n13 XFRONT.XFE_E.BN.n10 18.4942
R6093 XFRONT.XFE_E.BN.n17 XFRONT.XFE_E.BN.n16 18.4942
R6094 XFRONT.XFE_E.BN.n32 XFRONT.XFE_E.BN.n31 15.5414
R6095 XFRONT.XFE_E.BN.n27 XFRONT.XFE_E.BN.n26 11.6805
R6096 XFRONT.XFE_E.BN.n28 XFRONT.XFE_E.BN.n27 11.6805
R6097 XFRONT.XFE_E.BN.n29 XFRONT.XFE_E.BN.n28 11.6805
R6098 XFRONT.XFE_E.BN.n30 XFRONT.XFE_E.BN.n29 11.6805
R6099 XFRONT.XFE_E.BN.n18 XFRONT.XFE_E.BN.n17 11.6805
R6100 XFRONT.XFE_E.BN.n19 XFRONT.XFE_E.BN.n18 11.6805
R6101 XFRONT.XFE_E.BN.n13 XFRONT.XFE_E.BN.n12 11.6805
R6102 XFRONT.XFE_E.BN.n19 XFRONT.XFE_E.BN.n13 11.6805
R6103 XFRONT.XFE_E.BN.n17 XFRONT.XFE_E.BN.n14 11.6805
R6104 XFRONT.XFE_E.BN.n32 XFRONT.XFE_E.BN.n21 9.87478
R6105 XFRONT.XFE_E.BN.n8 XFRONT.XFE_E.BN.n7 8.36407
R6106 XFRONT.XFE_E.BN.n8 XFRONT.XFE_E.BN.n0 7.91407
R6107 XFRONT.XFE_E.BN.n25 XFRONT.XFE_E.BN.n24 7.17687
R6108 XFRONT.XFE_E.BN.n16 XFRONT.XFE_E.BN.n15 7.17687
R6109 XFRONT.XFE_E.BN.n11 XFRONT.XFE_E.BN.n10 7.17687
R6110 XFRONT.XFE_E.BN XFRONT.XFE_E.BN.n32 6.37876
R6111 XFRONT.XFE_E.BN.n2 XFRONT.XFE_E.BN.t9 5.7796
R6112 XFRONT.XFE_E.BN.n4 XFRONT.XFE_E.BN.t2 5.7796
R6113 XFRONT.XFE_E.BN.n0 XFRONT.XFE_E.BN.t0 5.73764
R6114 XFRONT.XFE_E.BN.n0 XFRONT.XFE_E.BN.t1 5.54817
R6115 XFRONT.XFE_E.BN.n2 XFRONT.XFE_E.BN.n1 5.38537
R6116 XFRONT.XFE_E.BN.n6 XFRONT.XFE_E.BN.n5 5.38537
R6117 XFRONT.XFE_E.BN.n4 XFRONT.XFE_E.BN.n3 5.38537
R6118 XFRONT.XFE_E.BN XFRONT.XFE_E.BN.n8 4.53963
R6119 XFRONT.XFE_E.BN.n26 XFRONT.XFE_E.BN.n25 4.42851
R6120 XFRONT.XFE_E.BN.n12 XFRONT.XFE_E.BN.n11 4.42851
R6121 XFRONT.XFE_E.BN.n15 XFRONT.XFE_E.BN.n14 4.42851
R6122 XFRONT.XFE_E.BN.n1 XFRONT.XFE_E.BN.t7 0.20525
R6123 XFRONT.XFE_E.BN.n1 XFRONT.XFE_E.BN.t8 0.20525
R6124 XFRONT.XFE_E.BN.n5 XFRONT.XFE_E.BN.t5 0.20525
R6125 XFRONT.XFE_E.BN.n5 XFRONT.XFE_E.BN.t6 0.20525
R6126 XFRONT.XFE_E.BN.n3 XFRONT.XFE_E.BN.t3 0.20525
R6127 XFRONT.XFE_E.BN.n3 XFRONT.XFE_E.BN.t4 0.20525
R6128 XFRONT.XFE_E.BN.n6 XFRONT.XFE_E.BN.n4 0.189974
R6129 XFRONT.XFE_E.BN.n24 XFRONT.XFE_E.BN.n23 0.1205
R6130 XFRONT.XFE_E.BN.n23 XFRONT.XFE_E.BN.n22 0.1205
R6131 XFRONT.XFE_E.BN.n31 XFRONT.XFE_E.BN.n22 0.1205
R6132 XFRONT.XFE_E.BN.n16 XFRONT.XFE_E.BN.n9 0.1205
R6133 XFRONT.XFE_E.BN.n20 XFRONT.XFE_E.BN.n10 0.1205
R6134 XFRONT.XFE_E.BN.n7 XFRONT.XFE_E.BN.n6 0.0952368
R6135 XFRONT.XFE_E.BN.n7 XFRONT.XFE_E.BN.n2 0.0952368
R6136 XFRONT.XFE_E.BN.n21 XFRONT.XFE_E.BN.n9 0.0485
R6137 XFRONT.XFE_E.BN.n21 XFRONT.XFE_E.BN.n20 0.0485
R6138 XFRONT.XFE_O.NREGEN.n7 XFRONT.XFE_O.NREGEN.n0 18.0069
R6139 XFRONT.XFE_O.NREGEN.n29 XFRONT.XFE_O.NREGEN.n22 18.0069
R6140 XFRONT.XFE_O.NREGEN.n10 XFRONT.XFE_O.NREGEN.n9 10.6614
R6141 XFRONT.XFE_O.NREGEN.n21 XFRONT.XFE_O.NREGEN.n20 10.6614
R6142 XFRONT.XFE_O.NREGEN.n18 XFRONT.XFE_O.NREGEN.n17 9.32836
R6143 XFRONT.XFE_O.NREGEN.n7 XFRONT.XFE_O.NREGEN.n6 6.11407
R6144 XFRONT.XFE_O.NREGEN.n29 XFRONT.XFE_O.NREGEN.n28 6.11407
R6145 XFRONT.XFE_O.NREGEN.n10 XFRONT.XFE_O.NREGEN.n7 6.10485
R6146 XFRONT.XFE_O.NREGEN.n12 XFRONT.XFE_O.NREGEN.t25 5.7796
R6147 XFRONT.XFE_O.NREGEN.n16 XFRONT.XFE_O.NREGEN.t18 5.7796
R6148 XFRONT.XFE_O.NREGEN.n18 XFRONT.XFE_O.NREGEN.n10 5.75267
R6149 XFRONT.XFE_O.NREGEN.n0 XFRONT.XFE_O.NREGEN.t16 5.73764
R6150 XFRONT.XFE_O.NREGEN.n22 XFRONT.XFE_O.NREGEN.t14 5.73764
R6151 XFRONT.XFE_O.NREGEN.n9 XFRONT.XFE_O.NREGEN.t31 5.59012
R6152 XFRONT.XFE_O.NREGEN.n20 XFRONT.XFE_O.NREGEN.t13 5.59012
R6153 XFRONT.XFE_O.NREGEN.n9 XFRONT.XFE_O.NREGEN.n8 5.57485
R6154 XFRONT.XFE_O.NREGEN.n20 XFRONT.XFE_O.NREGEN.n19 5.57485
R6155 XFRONT.XFE_O.NREGEN.n6 XFRONT.XFE_O.NREGEN.n1 5.57485
R6156 XFRONT.XFE_O.NREGEN.n5 XFRONT.XFE_O.NREGEN.n3 5.57485
R6157 XFRONT.XFE_O.NREGEN.n28 XFRONT.XFE_O.NREGEN.n23 5.57485
R6158 XFRONT.XFE_O.NREGEN.n27 XFRONT.XFE_O.NREGEN.n25 5.57485
R6159 XFRONT.XFE_O.NREGEN.n0 XFRONT.XFE_O.NREGEN.t17 5.54817
R6160 XFRONT.XFE_O.NREGEN.n22 XFRONT.XFE_O.NREGEN.t15 5.54817
R6161 XFRONT.XFE_O.NREGEN.n6 XFRONT.XFE_O.NREGEN.n2 5.38537
R6162 XFRONT.XFE_O.NREGEN.n5 XFRONT.XFE_O.NREGEN.n4 5.38537
R6163 XFRONT.XFE_O.NREGEN.n28 XFRONT.XFE_O.NREGEN.n24 5.38537
R6164 XFRONT.XFE_O.NREGEN.n27 XFRONT.XFE_O.NREGEN.n26 5.38537
R6165 XFRONT.XFE_O.NREGEN.n12 XFRONT.XFE_O.NREGEN.n11 5.38537
R6166 XFRONT.XFE_O.NREGEN.n14 XFRONT.XFE_O.NREGEN.n13 5.38537
R6167 XFRONT.XFE_O.NREGEN.n16 XFRONT.XFE_O.NREGEN.n15 5.38537
R6168 XFRONT.XFE_O.NREGEN.n30 XFRONT.XFE_O.NREGEN.n29 4.5005
R6169 XFRONT.XFE_O.NREGEN.n21 XFRONT.XFE_O.NREGEN.n18 2.46572
R6170 XFRONT.XFE_O.NREGEN.n30 XFRONT.XFE_O.NREGEN.n21 1.91789
R6171 XFRONT.XFE_O.NREGEN.n8 XFRONT.XFE_O.NREGEN.t33 0.20525
R6172 XFRONT.XFE_O.NREGEN.n8 XFRONT.XFE_O.NREGEN.t32 0.20525
R6173 XFRONT.XFE_O.NREGEN.n19 XFRONT.XFE_O.NREGEN.t11 0.20525
R6174 XFRONT.XFE_O.NREGEN.n19 XFRONT.XFE_O.NREGEN.t10 0.20525
R6175 XFRONT.XFE_O.NREGEN.n1 XFRONT.XFE_O.NREGEN.t1 0.20525
R6176 XFRONT.XFE_O.NREGEN.n1 XFRONT.XFE_O.NREGEN.t6 0.20525
R6177 XFRONT.XFE_O.NREGEN.n2 XFRONT.XFE_O.NREGEN.t28 0.20525
R6178 XFRONT.XFE_O.NREGEN.n2 XFRONT.XFE_O.NREGEN.t2 0.20525
R6179 XFRONT.XFE_O.NREGEN.n4 XFRONT.XFE_O.NREGEN.t7 0.20525
R6180 XFRONT.XFE_O.NREGEN.n4 XFRONT.XFE_O.NREGEN.t26 0.20525
R6181 XFRONT.XFE_O.NREGEN.n3 XFRONT.XFE_O.NREGEN.t8 0.20525
R6182 XFRONT.XFE_O.NREGEN.n3 XFRONT.XFE_O.NREGEN.t27 0.20525
R6183 XFRONT.XFE_O.NREGEN.n23 XFRONT.XFE_O.NREGEN.t29 0.20525
R6184 XFRONT.XFE_O.NREGEN.n23 XFRONT.XFE_O.NREGEN.t30 0.20525
R6185 XFRONT.XFE_O.NREGEN.n24 XFRONT.XFE_O.NREGEN.t3 0.20525
R6186 XFRONT.XFE_O.NREGEN.n24 XFRONT.XFE_O.NREGEN.t5 0.20525
R6187 XFRONT.XFE_O.NREGEN.n26 XFRONT.XFE_O.NREGEN.t4 0.20525
R6188 XFRONT.XFE_O.NREGEN.n26 XFRONT.XFE_O.NREGEN.t9 0.20525
R6189 XFRONT.XFE_O.NREGEN.n25 XFRONT.XFE_O.NREGEN.t12 0.20525
R6190 XFRONT.XFE_O.NREGEN.n25 XFRONT.XFE_O.NREGEN.t0 0.20525
R6191 XFRONT.XFE_O.NREGEN.n11 XFRONT.XFE_O.NREGEN.t23 0.20525
R6192 XFRONT.XFE_O.NREGEN.n11 XFRONT.XFE_O.NREGEN.t24 0.20525
R6193 XFRONT.XFE_O.NREGEN.n13 XFRONT.XFE_O.NREGEN.t21 0.20525
R6194 XFRONT.XFE_O.NREGEN.n13 XFRONT.XFE_O.NREGEN.t22 0.20525
R6195 XFRONT.XFE_O.NREGEN.n15 XFRONT.XFE_O.NREGEN.t19 0.20525
R6196 XFRONT.XFE_O.NREGEN.n15 XFRONT.XFE_O.NREGEN.t20 0.20525
R6197 XFRONT.XFE_O.NREGEN.n14 XFRONT.XFE_O.NREGEN.n12 0.189974
R6198 XFRONT.XFE_O.NREGEN.n6 XFRONT.XFE_O.NREGEN.n5 0.189974
R6199 XFRONT.XFE_O.NREGEN.n28 XFRONT.XFE_O.NREGEN.n27 0.189974
R6200 XFRONT.XFE_O.NREGEN.n17 XFRONT.XFE_O.NREGEN.n16 0.0952368
R6201 XFRONT.XFE_O.NREGEN.n17 XFRONT.XFE_O.NREGEN.n14 0.0952368
R6202 XFRONT.XFE_O.NREGEN XFRONT.XFE_O.NREGEN.n30 0.0396304
R6203 XFRONT.XFE_E.NREGEN.n7 XFRONT.XFE_E.NREGEN.n0 18.0069
R6204 XFRONT.XFE_E.NREGEN.n15 XFRONT.XFE_E.NREGEN.n8 18.0069
R6205 XFRONT.XFE_E.NREGEN.n29 XFRONT.XFE_E.NREGEN.n28 10.6614
R6206 XFRONT.XFE_E.NREGEN.n18 XFRONT.XFE_E.NREGEN.n17 10.6614
R6207 XFRONT.XFE_E.NREGEN.n26 XFRONT.XFE_E.NREGEN.n25 9.32836
R6208 XFRONT.XFE_E.NREGEN.n7 XFRONT.XFE_E.NREGEN.n6 6.11407
R6209 XFRONT.XFE_E.NREGEN.n15 XFRONT.XFE_E.NREGEN.n14 6.11407
R6210 XFRONT.XFE_E.NREGEN.n18 XFRONT.XFE_E.NREGEN.n15 6.10485
R6211 XFRONT.XFE_E.NREGEN.n20 XFRONT.XFE_E.NREGEN.t22 5.7796
R6212 XFRONT.XFE_E.NREGEN.n22 XFRONT.XFE_E.NREGEN.t15 5.7796
R6213 XFRONT.XFE_E.NREGEN.n26 XFRONT.XFE_E.NREGEN.n18 5.75267
R6214 XFRONT.XFE_E.NREGEN.n0 XFRONT.XFE_E.NREGEN.t14 5.73764
R6215 XFRONT.XFE_E.NREGEN.n8 XFRONT.XFE_E.NREGEN.t12 5.73764
R6216 XFRONT.XFE_E.NREGEN.n28 XFRONT.XFE_E.NREGEN.t30 5.59012
R6217 XFRONT.XFE_E.NREGEN.n17 XFRONT.XFE_E.NREGEN.t24 5.59012
R6218 XFRONT.XFE_E.NREGEN.n28 XFRONT.XFE_E.NREGEN.n27 5.57485
R6219 XFRONT.XFE_E.NREGEN.n17 XFRONT.XFE_E.NREGEN.n16 5.57485
R6220 XFRONT.XFE_E.NREGEN.n3 XFRONT.XFE_E.NREGEN.n1 5.57485
R6221 XFRONT.XFE_E.NREGEN.n6 XFRONT.XFE_E.NREGEN.n5 5.57485
R6222 XFRONT.XFE_E.NREGEN.n11 XFRONT.XFE_E.NREGEN.n9 5.57485
R6223 XFRONT.XFE_E.NREGEN.n14 XFRONT.XFE_E.NREGEN.n13 5.57485
R6224 XFRONT.XFE_E.NREGEN.n0 XFRONT.XFE_E.NREGEN.t13 5.54817
R6225 XFRONT.XFE_E.NREGEN.n8 XFRONT.XFE_E.NREGEN.t11 5.54817
R6226 XFRONT.XFE_E.NREGEN.n3 XFRONT.XFE_E.NREGEN.n2 5.38537
R6227 XFRONT.XFE_E.NREGEN.n6 XFRONT.XFE_E.NREGEN.n4 5.38537
R6228 XFRONT.XFE_E.NREGEN.n11 XFRONT.XFE_E.NREGEN.n10 5.38537
R6229 XFRONT.XFE_E.NREGEN.n14 XFRONT.XFE_E.NREGEN.n12 5.38537
R6230 XFRONT.XFE_E.NREGEN.n20 XFRONT.XFE_E.NREGEN.n19 5.38537
R6231 XFRONT.XFE_E.NREGEN.n24 XFRONT.XFE_E.NREGEN.n23 5.38537
R6232 XFRONT.XFE_E.NREGEN.n22 XFRONT.XFE_E.NREGEN.n21 5.38537
R6233 XFRONT.XFE_E.NREGEN XFRONT.XFE_E.NREGEN.n7 4.53963
R6234 XFRONT.XFE_E.NREGEN.n29 XFRONT.XFE_E.NREGEN.n26 2.46572
R6235 XFRONT.XFE_E.NREGEN XFRONT.XFE_E.NREGEN.n29 1.87876
R6236 XFRONT.XFE_E.NREGEN.n27 XFRONT.XFE_E.NREGEN.t29 0.20525
R6237 XFRONT.XFE_E.NREGEN.n27 XFRONT.XFE_E.NREGEN.t28 0.20525
R6238 XFRONT.XFE_E.NREGEN.n16 XFRONT.XFE_E.NREGEN.t23 0.20525
R6239 XFRONT.XFE_E.NREGEN.n16 XFRONT.XFE_E.NREGEN.t25 0.20525
R6240 XFRONT.XFE_E.NREGEN.n1 XFRONT.XFE_E.NREGEN.t3 0.20525
R6241 XFRONT.XFE_E.NREGEN.n1 XFRONT.XFE_E.NREGEN.t8 0.20525
R6242 XFRONT.XFE_E.NREGEN.n2 XFRONT.XFE_E.NREGEN.t1 0.20525
R6243 XFRONT.XFE_E.NREGEN.n2 XFRONT.XFE_E.NREGEN.t2 0.20525
R6244 XFRONT.XFE_E.NREGEN.n4 XFRONT.XFE_E.NREGEN.t33 0.20525
R6245 XFRONT.XFE_E.NREGEN.n4 XFRONT.XFE_E.NREGEN.t31 0.20525
R6246 XFRONT.XFE_E.NREGEN.n5 XFRONT.XFE_E.NREGEN.t27 0.20525
R6247 XFRONT.XFE_E.NREGEN.n5 XFRONT.XFE_E.NREGEN.t9 0.20525
R6248 XFRONT.XFE_E.NREGEN.n9 XFRONT.XFE_E.NREGEN.t7 0.20525
R6249 XFRONT.XFE_E.NREGEN.n9 XFRONT.XFE_E.NREGEN.t4 0.20525
R6250 XFRONT.XFE_E.NREGEN.n10 XFRONT.XFE_E.NREGEN.t26 0.20525
R6251 XFRONT.XFE_E.NREGEN.n10 XFRONT.XFE_E.NREGEN.t5 0.20525
R6252 XFRONT.XFE_E.NREGEN.n12 XFRONT.XFE_E.NREGEN.t32 0.20525
R6253 XFRONT.XFE_E.NREGEN.n12 XFRONT.XFE_E.NREGEN.t10 0.20525
R6254 XFRONT.XFE_E.NREGEN.n13 XFRONT.XFE_E.NREGEN.t0 0.20525
R6255 XFRONT.XFE_E.NREGEN.n13 XFRONT.XFE_E.NREGEN.t6 0.20525
R6256 XFRONT.XFE_E.NREGEN.n19 XFRONT.XFE_E.NREGEN.t20 0.20525
R6257 XFRONT.XFE_E.NREGEN.n19 XFRONT.XFE_E.NREGEN.t21 0.20525
R6258 XFRONT.XFE_E.NREGEN.n23 XFRONT.XFE_E.NREGEN.t18 0.20525
R6259 XFRONT.XFE_E.NREGEN.n23 XFRONT.XFE_E.NREGEN.t19 0.20525
R6260 XFRONT.XFE_E.NREGEN.n21 XFRONT.XFE_E.NREGEN.t16 0.20525
R6261 XFRONT.XFE_E.NREGEN.n21 XFRONT.XFE_E.NREGEN.t17 0.20525
R6262 XFRONT.XFE_E.NREGEN.n24 XFRONT.XFE_E.NREGEN.n22 0.189974
R6263 XFRONT.XFE_E.NREGEN.n6 XFRONT.XFE_E.NREGEN.n3 0.189974
R6264 XFRONT.XFE_E.NREGEN.n14 XFRONT.XFE_E.NREGEN.n11 0.189974
R6265 XFRONT.XFE_E.NREGEN.n25 XFRONT.XFE_E.NREGEN.n24 0.0952368
R6266 XFRONT.XFE_E.NREGEN.n25 XFRONT.XFE_E.NREGEN.n20 0.0952368
R6267 XFRONT.XFE_O.XN.n70 XFRONT.XFE_O.XN.t57 127.788
R6268 XFRONT.XFE_O.XN.t50 XFRONT.XFE_O.XN.n60 127.788
R6269 XFRONT.XFE_O.XN.n67 XFRONT.XFE_O.XN.t53 127.668
R6270 XFRONT.XFE_O.XN.n70 XFRONT.XFE_O.XN.t56 127.668
R6271 XFRONT.XFE_O.XN.t55 XFRONT.XFE_O.XN.n71 127.668
R6272 XFRONT.XFE_O.XN.t54 XFRONT.XFE_O.XN.n68 127.668
R6273 XFRONT.XFE_O.XN.t51 XFRONT.XFE_O.XN.n60 127.668
R6274 XFRONT.XFE_O.XN.n66 XFRONT.XFE_O.XN.t52 127.668
R6275 XFRONT.XFE_O.XN.n22 XFRONT.XFE_O.XN.t41 113.632
R6276 XFRONT.XFE_O.XN.n5 XFRONT.XFE_O.XN.t49 113.632
R6277 XFRONT.XFE_O.XN.n76 XFRONT.XFE_O.XN.t37 113.632
R6278 XFRONT.XFE_O.XN.t57 XFRONT.XFE_O.XN.n57 113.632
R6279 XFRONT.XFE_O.XN.n63 XFRONT.XFE_O.XN.t50 113.632
R6280 XFRONT.XFE_O.XN.n23 XFRONT.XFE_O.XN.t40 109.174
R6281 XFRONT.XFE_O.XN.n24 XFRONT.XFE_O.XN.t39 109.174
R6282 XFRONT.XFE_O.XN.n25 XFRONT.XFE_O.XN.t38 109.174
R6283 XFRONT.XFE_O.XN.n0 XFRONT.XFE_O.XN.t42 109.174
R6284 XFRONT.XFE_O.XN.n11 XFRONT.XFE_O.XN.t43 109.174
R6285 XFRONT.XFE_O.XN.n10 XFRONT.XFE_O.XN.t44 109.174
R6286 XFRONT.XFE_O.XN.n6 XFRONT.XFE_O.XN.t48 109.174
R6287 XFRONT.XFE_O.XN.n7 XFRONT.XFE_O.XN.t47 109.174
R6288 XFRONT.XFE_O.XN.n8 XFRONT.XFE_O.XN.t46 109.174
R6289 XFRONT.XFE_O.XN.n9 XFRONT.XFE_O.XN.t45 109.174
R6290 XFRONT.XFE_O.XN.n77 XFRONT.XFE_O.XN.t36 109.174
R6291 XFRONT.XFE_O.XN.n78 XFRONT.XFE_O.XN.t35 109.174
R6292 XFRONT.XFE_O.XN.t53 XFRONT.XFE_O.XN.n59 109.174
R6293 XFRONT.XFE_O.XN.t56 XFRONT.XFE_O.XN.n58 109.174
R6294 XFRONT.XFE_O.XN.n72 XFRONT.XFE_O.XN.t55 109.174
R6295 XFRONT.XFE_O.XN.n69 XFRONT.XFE_O.XN.t54 109.174
R6296 XFRONT.XFE_O.XN.n64 XFRONT.XFE_O.XN.t51 109.174
R6297 XFRONT.XFE_O.XN.t52 XFRONT.XFE_O.XN.n65 109.174
R6298 XFRONT.XFE_O.XN.n46 XFRONT.XFE_O.XN.n45 21.0284
R6299 XFRONT.XFE_O.XN.n54 XFRONT.XFE_O.XN.n53 18.9712
R6300 XFRONT.XFE_O.XN.n13 XFRONT.XFE_O.XN.n0 18.5723
R6301 XFRONT.XFE_O.XN.n24 XFRONT.XFE_O.XN.n21 18.4942
R6302 XFRONT.XFE_O.XN.n26 XFRONT.XFE_O.XN.n25 18.4942
R6303 XFRONT.XFE_O.XN.n12 XFRONT.XFE_O.XN.n11 18.4942
R6304 XFRONT.XFE_O.XN.n10 XFRONT.XFE_O.XN.n1 18.4942
R6305 XFRONT.XFE_O.XN.n7 XFRONT.XFE_O.XN.n4 18.4942
R6306 XFRONT.XFE_O.XN.n8 XFRONT.XFE_O.XN.n3 18.4942
R6307 XFRONT.XFE_O.XN.n9 XFRONT.XFE_O.XN.n2 18.4942
R6308 XFRONT.XFE_O.XN.n79 XFRONT.XFE_O.XN.n78 18.4942
R6309 XFRONT.XFE_O.XN.n61 XFRONT.XFE_O.XN.n59 18.4942
R6310 XFRONT.XFE_O.XN.n73 XFRONT.XFE_O.XN.n72 18.4942
R6311 XFRONT.XFE_O.XN.n69 XFRONT.XFE_O.XN.n56 18.4942
R6312 XFRONT.XFE_O.XN.n65 XFRONT.XFE_O.XN.n62 18.4942
R6313 XFRONT.XFE_O.XN.n80 XFRONT.XFE_O.XN.n79 16.6599
R6314 XFRONT.XFE_O.XN.n38 XFRONT.XFE_O.XN.n35 12.6712
R6315 XFRONT.XFE_O.XN.n24 XFRONT.XFE_O.XN.n23 11.6805
R6316 XFRONT.XFE_O.XN.n25 XFRONT.XFE_O.XN.n24 11.6805
R6317 XFRONT.XFE_O.XN.n11 XFRONT.XFE_O.XN.n0 11.6805
R6318 XFRONT.XFE_O.XN.n11 XFRONT.XFE_O.XN.n10 11.6805
R6319 XFRONT.XFE_O.XN.n7 XFRONT.XFE_O.XN.n6 11.6805
R6320 XFRONT.XFE_O.XN.n8 XFRONT.XFE_O.XN.n7 11.6805
R6321 XFRONT.XFE_O.XN.n9 XFRONT.XFE_O.XN.n8 11.6805
R6322 XFRONT.XFE_O.XN.n10 XFRONT.XFE_O.XN.n9 11.6805
R6323 XFRONT.XFE_O.XN.n78 XFRONT.XFE_O.XN.n77 11.6805
R6324 XFRONT.XFE_O.XN.n72 XFRONT.XFE_O.XN.n69 11.6805
R6325 XFRONT.XFE_O.XN.n72 XFRONT.XFE_O.XN.n58 11.6805
R6326 XFRONT.XFE_O.XN.n69 XFRONT.XFE_O.XN.n59 11.6805
R6327 XFRONT.XFE_O.XN.n65 XFRONT.XFE_O.XN.n64 11.6805
R6328 XFRONT.XFE_O.XN.n65 XFRONT.XFE_O.XN.n59 11.6805
R6329 XFRONT.XFE_O.XN.n75 XFRONT.XFE_O.XN.n55 10.8396
R6330 XFRONT.XFE_O.XN.n28 XFRONT.XFE_O.XN.n13 10.7748
R6331 XFRONT.XFE_O.XN.n38 XFRONT.XFE_O.XN.n37 9.44001
R6332 XFRONT.XFE_O.XN.n27 XFRONT.XFE_O.XN.n26 9.1385
R6333 XFRONT.XFE_O.XN.n75 XFRONT.XFE_O.XN.n74 9.0005
R6334 XFRONT.XFE_O.XN.n22 XFRONT.XFE_O.XN.n21 7.17687
R6335 XFRONT.XFE_O.XN.n5 XFRONT.XFE_O.XN.n4 7.17687
R6336 XFRONT.XFE_O.XN.n79 XFRONT.XFE_O.XN.n76 7.17687
R6337 XFRONT.XFE_O.XN.n73 XFRONT.XFE_O.XN.n57 7.17687
R6338 XFRONT.XFE_O.XN.n63 XFRONT.XFE_O.XN.n62 7.17687
R6339 XFRONT.XFE_O.XN.n39 XFRONT.XFE_O.XN.n28 6.41789
R6340 XFRONT.XFE_O.XN.n27 XFRONT.XFE_O.XN.n20 6.40336
R6341 XFRONT.XFE_O.XN.n15 XFRONT.XFE_O.XN.t2 5.7796
R6342 XFRONT.XFE_O.XN.n19 XFRONT.XFE_O.XN.t4 5.7796
R6343 XFRONT.XFE_O.XN.n41 XFRONT.XFE_O.XN.t16 5.73764
R6344 XFRONT.XFE_O.XN.n30 XFRONT.XFE_O.XN.t5 5.73764
R6345 XFRONT.XFE_O.XN.n32 XFRONT.XFE_O.XN.t31 5.73764
R6346 XFRONT.XFE_O.XN.n45 XFRONT.XFE_O.XN.t9 5.73764
R6347 XFRONT.XFE_O.XN.n80 XFRONT.XFE_O.XN.n75 5.63193
R6348 XFRONT.XFE_O.XN.n37 XFRONT.XFE_O.XN.t34 5.59012
R6349 XFRONT.XFE_O.XN.n37 XFRONT.XFE_O.XN.n36 5.57485
R6350 XFRONT.XFE_O.XN.n50 XFRONT.XFE_O.XN.n48 5.51014
R6351 XFRONT.XFE_O.XN.n53 XFRONT.XFE_O.XN.n47 5.4154
R6352 XFRONT.XFE_O.XN.n15 XFRONT.XFE_O.XN.n14 5.38537
R6353 XFRONT.XFE_O.XN.n17 XFRONT.XFE_O.XN.n16 5.38537
R6354 XFRONT.XFE_O.XN.n19 XFRONT.XFE_O.XN.n18 5.38537
R6355 XFRONT.XFE_O.XN.n41 XFRONT.XFE_O.XN.n40 5.32067
R6356 XFRONT.XFE_O.XN.n43 XFRONT.XFE_O.XN.n42 5.32067
R6357 XFRONT.XFE_O.XN.n30 XFRONT.XFE_O.XN.n29 5.32067
R6358 XFRONT.XFE_O.XN.n34 XFRONT.XFE_O.XN.n33 5.32067
R6359 XFRONT.XFE_O.XN.n32 XFRONT.XFE_O.XN.n31 5.32067
R6360 XFRONT.XFE_O.XN.n52 XFRONT.XFE_O.XN.n51 5.32067
R6361 XFRONT.XFE_O.XN.n50 XFRONT.XFE_O.XN.n49 5.32067
R6362 XFRONT.XFE_O.XN.n45 XFRONT.XFE_O.XN.n44 5.32067
R6363 XFRONT.XFE_O.XN.n81 XFRONT.XFE_O.XN.n80 4.5005
R6364 XFRONT.XFE_O.XN.n39 XFRONT.XFE_O.XN.n38 4.5005
R6365 XFRONT.XFE_O.XN.n23 XFRONT.XFE_O.XN.n22 4.42851
R6366 XFRONT.XFE_O.XN.n6 XFRONT.XFE_O.XN.n5 4.42851
R6367 XFRONT.XFE_O.XN.n77 XFRONT.XFE_O.XN.n76 4.42851
R6368 XFRONT.XFE_O.XN.n58 XFRONT.XFE_O.XN.n57 4.42851
R6369 XFRONT.XFE_O.XN.n64 XFRONT.XFE_O.XN.n63 4.42851
R6370 XFRONT.XFE_O.XN.n81 XFRONT.XFE_O.XN.n54 3.95267
R6371 XFRONT.XFE_O.XN.n28 XFRONT.XFE_O.XN.n27 2.93193
R6372 XFRONT.XFE_O.XN.n46 XFRONT.XFE_O.XN.n39 1.76137
R6373 XFRONT.XFE_O.XN.n54 XFRONT.XFE_O.XN.n46 1.72224
R6374 XFRONT.XFE_O.XN.n40 XFRONT.XFE_O.XN.t14 0.228
R6375 XFRONT.XFE_O.XN.n40 XFRONT.XFE_O.XN.t15 0.228
R6376 XFRONT.XFE_O.XN.n42 XFRONT.XFE_O.XN.t12 0.228
R6377 XFRONT.XFE_O.XN.n42 XFRONT.XFE_O.XN.t13 0.228
R6378 XFRONT.XFE_O.XN.n29 XFRONT.XFE_O.XN.t28 0.228
R6379 XFRONT.XFE_O.XN.n29 XFRONT.XFE_O.XN.t6 0.228
R6380 XFRONT.XFE_O.XN.n33 XFRONT.XFE_O.XN.t7 0.228
R6381 XFRONT.XFE_O.XN.n33 XFRONT.XFE_O.XN.t29 0.228
R6382 XFRONT.XFE_O.XN.n31 XFRONT.XFE_O.XN.t30 0.228
R6383 XFRONT.XFE_O.XN.n31 XFRONT.XFE_O.XN.t8 0.228
R6384 XFRONT.XFE_O.XN.n47 XFRONT.XFE_O.XN.t21 0.228
R6385 XFRONT.XFE_O.XN.n47 XFRONT.XFE_O.XN.t22 0.228
R6386 XFRONT.XFE_O.XN.n51 XFRONT.XFE_O.XN.t19 0.228
R6387 XFRONT.XFE_O.XN.n51 XFRONT.XFE_O.XN.t20 0.228
R6388 XFRONT.XFE_O.XN.n49 XFRONT.XFE_O.XN.t17 0.228
R6389 XFRONT.XFE_O.XN.n49 XFRONT.XFE_O.XN.t18 0.228
R6390 XFRONT.XFE_O.XN.n48 XFRONT.XFE_O.XN.t23 0.228
R6391 XFRONT.XFE_O.XN.n48 XFRONT.XFE_O.XN.t24 0.228
R6392 XFRONT.XFE_O.XN.n44 XFRONT.XFE_O.XN.t10 0.228
R6393 XFRONT.XFE_O.XN.n44 XFRONT.XFE_O.XN.t11 0.228
R6394 XFRONT.XFE_O.XN.n14 XFRONT.XFE_O.XN.t1 0.20525
R6395 XFRONT.XFE_O.XN.n14 XFRONT.XFE_O.XN.t0 0.20525
R6396 XFRONT.XFE_O.XN.n16 XFRONT.XFE_O.XN.t25 0.20525
R6397 XFRONT.XFE_O.XN.n16 XFRONT.XFE_O.XN.t27 0.20525
R6398 XFRONT.XFE_O.XN.n18 XFRONT.XFE_O.XN.t26 0.20525
R6399 XFRONT.XFE_O.XN.n18 XFRONT.XFE_O.XN.t3 0.20525
R6400 XFRONT.XFE_O.XN.n36 XFRONT.XFE_O.XN.t33 0.20525
R6401 XFRONT.XFE_O.XN.n36 XFRONT.XFE_O.XN.t32 0.20525
R6402 XFRONT.XFE_O.XN.n45 XFRONT.XFE_O.XN.n43 0.189974
R6403 XFRONT.XFE_O.XN.n43 XFRONT.XFE_O.XN.n41 0.189974
R6404 XFRONT.XFE_O.XN.n17 XFRONT.XFE_O.XN.n15 0.189974
R6405 XFRONT.XFE_O.XN.n34 XFRONT.XFE_O.XN.n32 0.189974
R6406 XFRONT.XFE_O.XN.n52 XFRONT.XFE_O.XN.n50 0.189974
R6407 XFRONT.XFE_O.XN.n35 XFRONT.XFE_O.XN.n34 0.166289
R6408 XFRONT.XFE_O.XN.n26 XFRONT.XFE_O.XN.n21 0.1205
R6409 XFRONT.XFE_O.XN.n4 XFRONT.XFE_O.XN.n3 0.1205
R6410 XFRONT.XFE_O.XN.n3 XFRONT.XFE_O.XN.n2 0.1205
R6411 XFRONT.XFE_O.XN.n2 XFRONT.XFE_O.XN.n1 0.1205
R6412 XFRONT.XFE_O.XN.n62 XFRONT.XFE_O.XN.n61 0.1205
R6413 XFRONT.XFE_O.XN.n67 XFRONT.XFE_O.XN.n66 0.1205
R6414 XFRONT.XFE_O.XN.n66 XFRONT.XFE_O.XN.n60 0.1205
R6415 XFRONT.XFE_O.XN.n71 XFRONT.XFE_O.XN.n70 0.1205
R6416 XFRONT.XFE_O.XN.n12 XFRONT.XFE_O.XN.n1 0.114816
R6417 XFRONT.XFE_O.XN.n61 XFRONT.XFE_O.XN.n56 0.114816
R6418 XFRONT.XFE_O.XN.n68 XFRONT.XFE_O.XN.n67 0.114816
R6419 XFRONT.XFE_O.XN.n20 XFRONT.XFE_O.XN.n19 0.0952368
R6420 XFRONT.XFE_O.XN.n20 XFRONT.XFE_O.XN.n17 0.0952368
R6421 XFRONT.XFE_O.XN.n53 XFRONT.XFE_O.XN.n52 0.0952368
R6422 XFRONT.XFE_O.XN.n71 XFRONT.XFE_O.XN.n55 0.0785
R6423 XFRONT.XFE_O.XN.n74 XFRONT.XFE_O.XN.n73 0.0785
R6424 XFRONT.XFE_O.XN XFRONT.XFE_O.XN.n81 0.0396304
R6425 XFRONT.XFE_O.XN.n13 XFRONT.XFE_O.XN.n12 0.0241842
R6426 XFRONT.XFE_O.XN.n35 XFRONT.XFE_O.XN.n30 0.0241842
R6427 XFRONT.XFE_O.XN.n74 XFRONT.XFE_O.XN.n56 0.0241842
R6428 XFRONT.XFE_O.XN.n68 XFRONT.XFE_O.XN.n55 0.0241842
R6429 XFRONT.XFE_O.XP.n8 XFRONT.XFE_O.XP.t57 127.788
R6430 XFRONT.XFE_O.XP.t50 XFRONT.XFE_O.XP.n0 127.668
R6431 XFRONT.XFE_O.XP.t51 XFRONT.XFE_O.XP.n17 127.668
R6432 XFRONT.XFE_O.XP.n16 XFRONT.XFE_O.XP.t52 127.668
R6433 XFRONT.XFE_O.XP.n15 XFRONT.XFE_O.XP.t53 127.668
R6434 XFRONT.XFE_O.XP.t54 XFRONT.XFE_O.XP.n3 127.668
R6435 XFRONT.XFE_O.XP.t55 XFRONT.XFE_O.XP.n9 127.668
R6436 XFRONT.XFE_O.XP.n8 XFRONT.XFE_O.XP.t56 127.668
R6437 XFRONT.XFE_O.XP.n22 XFRONT.XFE_O.XP.t37 113.632
R6438 XFRONT.XFE_O.XP.t57 XFRONT.XFE_O.XP.n6 113.632
R6439 XFRONT.XFE_O.XP.n74 XFRONT.XFE_O.XP.t38 113.632
R6440 XFRONT.XFE_O.XP.n55 XFRONT.XFE_O.XP.t42 113.632
R6441 XFRONT.XFE_O.XP.n23 XFRONT.XFE_O.XP.t36 109.174
R6442 XFRONT.XFE_O.XP.n24 XFRONT.XFE_O.XP.t35 109.174
R6443 XFRONT.XFE_O.XP.n19 XFRONT.XFE_O.XP.t50 109.174
R6444 XFRONT.XFE_O.XP.n18 XFRONT.XFE_O.XP.t51 109.174
R6445 XFRONT.XFE_O.XP.t52 XFRONT.XFE_O.XP.n2 109.174
R6446 XFRONT.XFE_O.XP.t53 XFRONT.XFE_O.XP.n14 109.174
R6447 XFRONT.XFE_O.XP.n4 XFRONT.XFE_O.XP.t54 109.174
R6448 XFRONT.XFE_O.XP.n10 XFRONT.XFE_O.XP.t55 109.174
R6449 XFRONT.XFE_O.XP.t56 XFRONT.XFE_O.XP.n7 109.174
R6450 XFRONT.XFE_O.XP.n77 XFRONT.XFE_O.XP.t41 109.174
R6451 XFRONT.XFE_O.XP.n76 XFRONT.XFE_O.XP.t40 109.174
R6452 XFRONT.XFE_O.XP.n75 XFRONT.XFE_O.XP.t39 109.174
R6453 XFRONT.XFE_O.XP.n64 XFRONT.XFE_O.XP.t49 109.174
R6454 XFRONT.XFE_O.XP.n63 XFRONT.XFE_O.XP.t48 109.174
R6455 XFRONT.XFE_O.XP.n62 XFRONT.XFE_O.XP.t47 109.174
R6456 XFRONT.XFE_O.XP.n53 XFRONT.XFE_O.XP.t46 109.174
R6457 XFRONT.XFE_O.XP.n58 XFRONT.XFE_O.XP.t45 109.174
R6458 XFRONT.XFE_O.XP.n57 XFRONT.XFE_O.XP.t44 109.174
R6459 XFRONT.XFE_O.XP.n56 XFRONT.XFE_O.XP.t43 109.174
R6460 XFRONT.XFE_O.XP.n40 XFRONT.XFE_O.XP.n39 21.4784
R6461 XFRONT.XFE_O.XP.n33 XFRONT.XFE_O.XP.n32 21.4784
R6462 XFRONT.XFE_O.XP.n25 XFRONT.XFE_O.XP.n24 18.4942
R6463 XFRONT.XFE_O.XP.n20 XFRONT.XFE_O.XP.n19 18.4942
R6464 XFRONT.XFE_O.XP.n18 XFRONT.XFE_O.XP.n1 18.4942
R6465 XFRONT.XFE_O.XP.n5 XFRONT.XFE_O.XP.n2 18.4942
R6466 XFRONT.XFE_O.XP.n14 XFRONT.XFE_O.XP.n13 18.4942
R6467 XFRONT.XFE_O.XP.n12 XFRONT.XFE_O.XP.n4 18.4942
R6468 XFRONT.XFE_O.XP.n11 XFRONT.XFE_O.XP.n10 18.4942
R6469 XFRONT.XFE_O.XP.n78 XFRONT.XFE_O.XP.n77 18.4942
R6470 XFRONT.XFE_O.XP.n76 XFRONT.XFE_O.XP.n73 18.4942
R6471 XFRONT.XFE_O.XP.n65 XFRONT.XFE_O.XP.n64 18.4942
R6472 XFRONT.XFE_O.XP.n63 XFRONT.XFE_O.XP.n52 18.4942
R6473 XFRONT.XFE_O.XP.n62 XFRONT.XFE_O.XP.n61 18.4942
R6474 XFRONT.XFE_O.XP.n60 XFRONT.XFE_O.XP.n53 18.4942
R6475 XFRONT.XFE_O.XP.n59 XFRONT.XFE_O.XP.n58 18.4942
R6476 XFRONT.XFE_O.XP.n57 XFRONT.XFE_O.XP.n54 18.4942
R6477 XFRONT.XFE_O.XP.n26 XFRONT.XFE_O.XP.n25 16.2099
R6478 XFRONT.XFE_O.XP.n50 XFRONT.XFE_O.XP.n47 13.287
R6479 XFRONT.XFE_O.XP.n24 XFRONT.XFE_O.XP.n23 11.6805
R6480 XFRONT.XFE_O.XP.n19 XFRONT.XFE_O.XP.n18 11.6805
R6481 XFRONT.XFE_O.XP.n18 XFRONT.XFE_O.XP.n2 11.6805
R6482 XFRONT.XFE_O.XP.n14 XFRONT.XFE_O.XP.n2 11.6805
R6483 XFRONT.XFE_O.XP.n14 XFRONT.XFE_O.XP.n4 11.6805
R6484 XFRONT.XFE_O.XP.n10 XFRONT.XFE_O.XP.n4 11.6805
R6485 XFRONT.XFE_O.XP.n10 XFRONT.XFE_O.XP.n7 11.6805
R6486 XFRONT.XFE_O.XP.n77 XFRONT.XFE_O.XP.n76 11.6805
R6487 XFRONT.XFE_O.XP.n76 XFRONT.XFE_O.XP.n75 11.6805
R6488 XFRONT.XFE_O.XP.n64 XFRONT.XFE_O.XP.n63 11.6805
R6489 XFRONT.XFE_O.XP.n63 XFRONT.XFE_O.XP.n62 11.6805
R6490 XFRONT.XFE_O.XP.n62 XFRONT.XFE_O.XP.n53 11.6805
R6491 XFRONT.XFE_O.XP.n58 XFRONT.XFE_O.XP.n53 11.6805
R6492 XFRONT.XFE_O.XP.n58 XFRONT.XFE_O.XP.n57 11.6805
R6493 XFRONT.XFE_O.XP.n57 XFRONT.XFE_O.XP.n56 11.6805
R6494 XFRONT.XFE_O.XP.n80 XFRONT.XFE_O.XP.n65 11.3628
R6495 XFRONT.XFE_O.XP.n21 XFRONT.XFE_O.XP.n0 11.2176
R6496 XFRONT.XFE_O.XP.n33 XFRONT.XFE_O.XP.n26 9.3918
R6497 XFRONT.XFE_O.XP.n21 XFRONT.XFE_O.XP.n20 9.3785
R6498 XFRONT.XFE_O.XP.n79 XFRONT.XFE_O.XP.n78 9.3785
R6499 XFRONT.XFE_O.XP.n50 XFRONT.XFE_O.XP.n49 8.99001
R6500 XFRONT.XFE_O.XP.n25 XFRONT.XFE_O.XP.n22 7.17687
R6501 XFRONT.XFE_O.XP.n11 XFRONT.XFE_O.XP.n6 7.17687
R6502 XFRONT.XFE_O.XP.n74 XFRONT.XFE_O.XP.n73 7.17687
R6503 XFRONT.XFE_O.XP.n55 XFRONT.XFE_O.XP.n54 7.17687
R6504 XFRONT.XFE_O.XP.n79 XFRONT.XFE_O.XP.n72 6.40336
R6505 XFRONT.XFE_O.XP.n26 XFRONT.XFE_O.XP.n21 6.08193
R6506 XFRONT.XFE_O.XP.n67 XFRONT.XFE_O.XP.t23 5.7796
R6507 XFRONT.XFE_O.XP.n71 XFRONT.XFE_O.XP.t5 5.7796
R6508 XFRONT.XFE_O.XP.n39 XFRONT.XFE_O.XP.t13 5.73764
R6509 XFRONT.XFE_O.XP.n42 XFRONT.XFE_O.XP.t34 5.73764
R6510 XFRONT.XFE_O.XP.n28 XFRONT.XFE_O.XP.t21 5.73764
R6511 XFRONT.XFE_O.XP.n32 XFRONT.XFE_O.XP.t14 5.73764
R6512 XFRONT.XFE_O.XP.n35 XFRONT.XFE_O.XP.t6 5.73764
R6513 XFRONT.XFE_O.XP.n49 XFRONT.XFE_O.XP.t24 5.59012
R6514 XFRONT.XFE_O.XP.n49 XFRONT.XFE_O.XP.n48 5.57485
R6515 XFRONT.XFE_O.XP.n47 XFRONT.XFE_O.XP.t30 5.54817
R6516 XFRONT.XFE_O.XP.n67 XFRONT.XFE_O.XP.n66 5.38537
R6517 XFRONT.XFE_O.XP.n69 XFRONT.XFE_O.XP.n68 5.38537
R6518 XFRONT.XFE_O.XP.n71 XFRONT.XFE_O.XP.n70 5.38537
R6519 XFRONT.XFE_O.XP.n42 XFRONT.XFE_O.XP.n41 5.32067
R6520 XFRONT.XFE_O.XP.n44 XFRONT.XFE_O.XP.n43 5.32067
R6521 XFRONT.XFE_O.XP.n46 XFRONT.XFE_O.XP.n45 5.32067
R6522 XFRONT.XFE_O.XP.n28 XFRONT.XFE_O.XP.n27 5.32067
R6523 XFRONT.XFE_O.XP.n30 XFRONT.XFE_O.XP.n29 5.32067
R6524 XFRONT.XFE_O.XP.n32 XFRONT.XFE_O.XP.n31 5.32067
R6525 XFRONT.XFE_O.XP.n39 XFRONT.XFE_O.XP.n38 5.32067
R6526 XFRONT.XFE_O.XP.n37 XFRONT.XFE_O.XP.n36 5.32067
R6527 XFRONT.XFE_O.XP.n35 XFRONT.XFE_O.XP.n34 5.32067
R6528 XFRONT.XFE_O.XP.n51 XFRONT.XFE_O.XP.n50 4.5005
R6529 XFRONT.XFE_O.XP.n81 XFRONT.XFE_O.XP.n80 4.5005
R6530 XFRONT.XFE_O.XP.n23 XFRONT.XFE_O.XP.n22 4.42851
R6531 XFRONT.XFE_O.XP.n7 XFRONT.XFE_O.XP.n6 4.42851
R6532 XFRONT.XFE_O.XP.n75 XFRONT.XFE_O.XP.n74 4.42851
R6533 XFRONT.XFE_O.XP.n56 XFRONT.XFE_O.XP.n55 4.42851
R6534 XFRONT.XFE_O.XP.n80 XFRONT.XFE_O.XP.n79 2.48193
R6535 XFRONT.XFE_O.XP.n51 XFRONT.XFE_O.XP.n40 2.38746
R6536 XFRONT.XFE_O.XP.n40 XFRONT.XFE_O.XP.n33 1.72224
R6537 XFRONT.XFE_O.XP.n81 XFRONT.XFE_O.XP.n51 1.60485
R6538 XFRONT.XFE_O.XP.n41 XFRONT.XFE_O.XP.t32 0.228
R6539 XFRONT.XFE_O.XP.n41 XFRONT.XFE_O.XP.t33 0.228
R6540 XFRONT.XFE_O.XP.n43 XFRONT.XFE_O.XP.t28 0.228
R6541 XFRONT.XFE_O.XP.n43 XFRONT.XFE_O.XP.t29 0.228
R6542 XFRONT.XFE_O.XP.n45 XFRONT.XFE_O.XP.t31 0.228
R6543 XFRONT.XFE_O.XP.n45 XFRONT.XFE_O.XP.t27 0.228
R6544 XFRONT.XFE_O.XP.n27 XFRONT.XFE_O.XP.t19 0.228
R6545 XFRONT.XFE_O.XP.n27 XFRONT.XFE_O.XP.t20 0.228
R6546 XFRONT.XFE_O.XP.n29 XFRONT.XFE_O.XP.t17 0.228
R6547 XFRONT.XFE_O.XP.n29 XFRONT.XFE_O.XP.t18 0.228
R6548 XFRONT.XFE_O.XP.n31 XFRONT.XFE_O.XP.t15 0.228
R6549 XFRONT.XFE_O.XP.n31 XFRONT.XFE_O.XP.t16 0.228
R6550 XFRONT.XFE_O.XP.n38 XFRONT.XFE_O.XP.t11 0.228
R6551 XFRONT.XFE_O.XP.n38 XFRONT.XFE_O.XP.t12 0.228
R6552 XFRONT.XFE_O.XP.n36 XFRONT.XFE_O.XP.t9 0.228
R6553 XFRONT.XFE_O.XP.n36 XFRONT.XFE_O.XP.t10 0.228
R6554 XFRONT.XFE_O.XP.n34 XFRONT.XFE_O.XP.t7 0.228
R6555 XFRONT.XFE_O.XP.n34 XFRONT.XFE_O.XP.t8 0.228
R6556 XFRONT.XFE_O.XP.n66 XFRONT.XFE_O.XP.t3 0.20525
R6557 XFRONT.XFE_O.XP.n66 XFRONT.XFE_O.XP.t22 0.20525
R6558 XFRONT.XFE_O.XP.n68 XFRONT.XFE_O.XP.t4 0.20525
R6559 XFRONT.XFE_O.XP.n68 XFRONT.XFE_O.XP.t1 0.20525
R6560 XFRONT.XFE_O.XP.n70 XFRONT.XFE_O.XP.t0 0.20525
R6561 XFRONT.XFE_O.XP.n70 XFRONT.XFE_O.XP.t2 0.20525
R6562 XFRONT.XFE_O.XP.n48 XFRONT.XFE_O.XP.t25 0.20525
R6563 XFRONT.XFE_O.XP.n48 XFRONT.XFE_O.XP.t26 0.20525
R6564 XFRONT.XFE_O.XP.n37 XFRONT.XFE_O.XP.n35 0.189974
R6565 XFRONT.XFE_O.XP.n39 XFRONT.XFE_O.XP.n37 0.189974
R6566 XFRONT.XFE_O.XP.n69 XFRONT.XFE_O.XP.n67 0.189974
R6567 XFRONT.XFE_O.XP.n47 XFRONT.XFE_O.XP.n46 0.189974
R6568 XFRONT.XFE_O.XP.n46 XFRONT.XFE_O.XP.n44 0.189974
R6569 XFRONT.XFE_O.XP.n44 XFRONT.XFE_O.XP.n42 0.189974
R6570 XFRONT.XFE_O.XP.n32 XFRONT.XFE_O.XP.n30 0.189974
R6571 XFRONT.XFE_O.XP.n30 XFRONT.XFE_O.XP.n28 0.189974
R6572 XFRONT.XFE_O.XP.n12 XFRONT.XFE_O.XP.n11 0.1205
R6573 XFRONT.XFE_O.XP.n13 XFRONT.XFE_O.XP.n12 0.1205
R6574 XFRONT.XFE_O.XP.n13 XFRONT.XFE_O.XP.n5 0.1205
R6575 XFRONT.XFE_O.XP.n5 XFRONT.XFE_O.XP.n1 0.1205
R6576 XFRONT.XFE_O.XP.n20 XFRONT.XFE_O.XP.n1 0.1205
R6577 XFRONT.XFE_O.XP.n9 XFRONT.XFE_O.XP.n8 0.1205
R6578 XFRONT.XFE_O.XP.n9 XFRONT.XFE_O.XP.n3 0.1205
R6579 XFRONT.XFE_O.XP.n15 XFRONT.XFE_O.XP.n3 0.1205
R6580 XFRONT.XFE_O.XP.n16 XFRONT.XFE_O.XP.n15 0.1205
R6581 XFRONT.XFE_O.XP.n17 XFRONT.XFE_O.XP.n16 0.1205
R6582 XFRONT.XFE_O.XP.n17 XFRONT.XFE_O.XP.n0 0.1205
R6583 XFRONT.XFE_O.XP.n78 XFRONT.XFE_O.XP.n73 0.1205
R6584 XFRONT.XFE_O.XP.n65 XFRONT.XFE_O.XP.n52 0.1205
R6585 XFRONT.XFE_O.XP.n61 XFRONT.XFE_O.XP.n52 0.1205
R6586 XFRONT.XFE_O.XP.n61 XFRONT.XFE_O.XP.n60 0.1205
R6587 XFRONT.XFE_O.XP.n60 XFRONT.XFE_O.XP.n59 0.1205
R6588 XFRONT.XFE_O.XP.n59 XFRONT.XFE_O.XP.n54 0.1205
R6589 XFRONT.XFE_O.XP.n72 XFRONT.XFE_O.XP.n71 0.0952368
R6590 XFRONT.XFE_O.XP.n72 XFRONT.XFE_O.XP.n69 0.0952368
R6591 XFRONT.XFE_O.XP XFRONT.XFE_O.XP.n81 0.0396304
R6592 XFRONT.XFE_E.XP.t50 XFRONT.XFE_E.XP.n40 127.788
R6593 XFRONT.XFE_E.XP.t57 XFRONT.XFE_E.XP.n29 127.668
R6594 XFRONT.XFE_E.XP.n40 XFRONT.XFE_E.XP.t51 127.668
R6595 XFRONT.XFE_E.XP.n39 XFRONT.XFE_E.XP.t52 127.668
R6596 XFRONT.XFE_E.XP.n38 XFRONT.XFE_E.XP.t53 127.668
R6597 XFRONT.XFE_E.XP.n37 XFRONT.XFE_E.XP.t54 127.668
R6598 XFRONT.XFE_E.XP.n36 XFRONT.XFE_E.XP.t55 127.668
R6599 XFRONT.XFE_E.XP.n35 XFRONT.XFE_E.XP.t56 127.668
R6600 XFRONT.XFE_E.XP.n22 XFRONT.XFE_E.XP.t41 113.632
R6601 XFRONT.XFE_E.XP.n5 XFRONT.XFE_E.XP.t49 113.632
R6602 XFRONT.XFE_E.XP.n51 XFRONT.XFE_E.XP.t35 113.632
R6603 XFRONT.XFE_E.XP.n41 XFRONT.XFE_E.XP.t50 113.632
R6604 XFRONT.XFE_E.XP.n23 XFRONT.XFE_E.XP.t40 109.174
R6605 XFRONT.XFE_E.XP.n24 XFRONT.XFE_E.XP.t39 109.174
R6606 XFRONT.XFE_E.XP.n25 XFRONT.XFE_E.XP.t38 109.174
R6607 XFRONT.XFE_E.XP.n6 XFRONT.XFE_E.XP.t48 109.174
R6608 XFRONT.XFE_E.XP.n7 XFRONT.XFE_E.XP.t47 109.174
R6609 XFRONT.XFE_E.XP.n8 XFRONT.XFE_E.XP.t46 109.174
R6610 XFRONT.XFE_E.XP.n9 XFRONT.XFE_E.XP.t45 109.174
R6611 XFRONT.XFE_E.XP.n10 XFRONT.XFE_E.XP.t44 109.174
R6612 XFRONT.XFE_E.XP.n11 XFRONT.XFE_E.XP.t43 109.174
R6613 XFRONT.XFE_E.XP.n12 XFRONT.XFE_E.XP.t42 109.174
R6614 XFRONT.XFE_E.XP.n53 XFRONT.XFE_E.XP.t37 109.174
R6615 XFRONT.XFE_E.XP.n52 XFRONT.XFE_E.XP.t36 109.174
R6616 XFRONT.XFE_E.XP.n48 XFRONT.XFE_E.XP.t57 109.174
R6617 XFRONT.XFE_E.XP.n42 XFRONT.XFE_E.XP.t51 109.174
R6618 XFRONT.XFE_E.XP.n43 XFRONT.XFE_E.XP.t52 109.174
R6619 XFRONT.XFE_E.XP.n44 XFRONT.XFE_E.XP.t53 109.174
R6620 XFRONT.XFE_E.XP.n45 XFRONT.XFE_E.XP.t54 109.174
R6621 XFRONT.XFE_E.XP.n46 XFRONT.XFE_E.XP.t55 109.174
R6622 XFRONT.XFE_E.XP.n47 XFRONT.XFE_E.XP.t56 109.174
R6623 XFRONT.XFE_E.XP.n69 XFRONT.XFE_E.XP.n68 21.4784
R6624 XFRONT.XFE_E.XP.n62 XFRONT.XFE_E.XP.n61 21.4784
R6625 XFRONT.XFE_E.XP.n24 XFRONT.XFE_E.XP.n21 18.4942
R6626 XFRONT.XFE_E.XP.n26 XFRONT.XFE_E.XP.n25 18.4942
R6627 XFRONT.XFE_E.XP.n7 XFRONT.XFE_E.XP.n4 18.4942
R6628 XFRONT.XFE_E.XP.n8 XFRONT.XFE_E.XP.n3 18.4942
R6629 XFRONT.XFE_E.XP.n9 XFRONT.XFE_E.XP.n2 18.4942
R6630 XFRONT.XFE_E.XP.n10 XFRONT.XFE_E.XP.n1 18.4942
R6631 XFRONT.XFE_E.XP.n11 XFRONT.XFE_E.XP.n0 18.4942
R6632 XFRONT.XFE_E.XP.n13 XFRONT.XFE_E.XP.n12 18.4942
R6633 XFRONT.XFE_E.XP.n54 XFRONT.XFE_E.XP.n53 18.4942
R6634 XFRONT.XFE_E.XP.n49 XFRONT.XFE_E.XP.n48 18.4942
R6635 XFRONT.XFE_E.XP.n43 XFRONT.XFE_E.XP.n34 18.4942
R6636 XFRONT.XFE_E.XP.n44 XFRONT.XFE_E.XP.n33 18.4942
R6637 XFRONT.XFE_E.XP.n45 XFRONT.XFE_E.XP.n32 18.4942
R6638 XFRONT.XFE_E.XP.n46 XFRONT.XFE_E.XP.n31 18.4942
R6639 XFRONT.XFE_E.XP.n47 XFRONT.XFE_E.XP.n30 18.4942
R6640 XFRONT.XFE_E.XP.n55 XFRONT.XFE_E.XP.n54 16.2099
R6641 XFRONT.XFE_E.XP.n79 XFRONT.XFE_E.XP.n76 13.287
R6642 XFRONT.XFE_E.XP.n24 XFRONT.XFE_E.XP.n23 11.6805
R6643 XFRONT.XFE_E.XP.n25 XFRONT.XFE_E.XP.n24 11.6805
R6644 XFRONT.XFE_E.XP.n7 XFRONT.XFE_E.XP.n6 11.6805
R6645 XFRONT.XFE_E.XP.n8 XFRONT.XFE_E.XP.n7 11.6805
R6646 XFRONT.XFE_E.XP.n9 XFRONT.XFE_E.XP.n8 11.6805
R6647 XFRONT.XFE_E.XP.n10 XFRONT.XFE_E.XP.n9 11.6805
R6648 XFRONT.XFE_E.XP.n11 XFRONT.XFE_E.XP.n10 11.6805
R6649 XFRONT.XFE_E.XP.n12 XFRONT.XFE_E.XP.n11 11.6805
R6650 XFRONT.XFE_E.XP.n53 XFRONT.XFE_E.XP.n52 11.6805
R6651 XFRONT.XFE_E.XP.n43 XFRONT.XFE_E.XP.n42 11.6805
R6652 XFRONT.XFE_E.XP.n44 XFRONT.XFE_E.XP.n43 11.6805
R6653 XFRONT.XFE_E.XP.n45 XFRONT.XFE_E.XP.n44 11.6805
R6654 XFRONT.XFE_E.XP.n46 XFRONT.XFE_E.XP.n45 11.6805
R6655 XFRONT.XFE_E.XP.n47 XFRONT.XFE_E.XP.n46 11.6805
R6656 XFRONT.XFE_E.XP.n48 XFRONT.XFE_E.XP.n47 11.6805
R6657 XFRONT.XFE_E.XP.n28 XFRONT.XFE_E.XP.n13 11.3628
R6658 XFRONT.XFE_E.XP.n50 XFRONT.XFE_E.XP.n29 11.2176
R6659 XFRONT.XFE_E.XP.n62 XFRONT.XFE_E.XP.n55 9.3918
R6660 XFRONT.XFE_E.XP.n27 XFRONT.XFE_E.XP.n26 9.3785
R6661 XFRONT.XFE_E.XP.n50 XFRONT.XFE_E.XP.n49 9.3785
R6662 XFRONT.XFE_E.XP.n79 XFRONT.XFE_E.XP.n78 8.99001
R6663 XFRONT.XFE_E.XP.n22 XFRONT.XFE_E.XP.n21 7.17687
R6664 XFRONT.XFE_E.XP.n5 XFRONT.XFE_E.XP.n4 7.17687
R6665 XFRONT.XFE_E.XP.n54 XFRONT.XFE_E.XP.n51 7.17687
R6666 XFRONT.XFE_E.XP.n41 XFRONT.XFE_E.XP.n34 7.17687
R6667 XFRONT.XFE_E.XP.n27 XFRONT.XFE_E.XP.n20 6.40336
R6668 XFRONT.XFE_E.XP.n55 XFRONT.XFE_E.XP.n50 6.08193
R6669 XFRONT.XFE_E.XP.n15 XFRONT.XFE_E.XP.t3 5.7796
R6670 XFRONT.XFE_E.XP.n17 XFRONT.XFE_E.XP.t21 5.7796
R6671 XFRONT.XFE_E.XP.n64 XFRONT.XFE_E.XP.t12 5.73764
R6672 XFRONT.XFE_E.XP.n71 XFRONT.XFE_E.XP.t26 5.73764
R6673 XFRONT.XFE_E.XP.n61 XFRONT.XFE_E.XP.t13 5.73764
R6674 XFRONT.XFE_E.XP.n58 XFRONT.XFE_E.XP.t14 5.73764
R6675 XFRONT.XFE_E.XP.n68 XFRONT.XFE_E.XP.t5 5.73764
R6676 XFRONT.XFE_E.XP.n78 XFRONT.XFE_E.XP.t22 5.59012
R6677 XFRONT.XFE_E.XP.n78 XFRONT.XFE_E.XP.n77 5.57485
R6678 XFRONT.XFE_E.XP.n76 XFRONT.XFE_E.XP.t29 5.54817
R6679 XFRONT.XFE_E.XP.n15 XFRONT.XFE_E.XP.n14 5.38537
R6680 XFRONT.XFE_E.XP.n19 XFRONT.XFE_E.XP.n18 5.38537
R6681 XFRONT.XFE_E.XP.n17 XFRONT.XFE_E.XP.n16 5.38537
R6682 XFRONT.XFE_E.XP.n64 XFRONT.XFE_E.XP.n63 5.32067
R6683 XFRONT.XFE_E.XP.n66 XFRONT.XFE_E.XP.n65 5.32067
R6684 XFRONT.XFE_E.XP.n75 XFRONT.XFE_E.XP.n74 5.32067
R6685 XFRONT.XFE_E.XP.n73 XFRONT.XFE_E.XP.n72 5.32067
R6686 XFRONT.XFE_E.XP.n71 XFRONT.XFE_E.XP.n70 5.32067
R6687 XFRONT.XFE_E.XP.n61 XFRONT.XFE_E.XP.n56 5.32067
R6688 XFRONT.XFE_E.XP.n60 XFRONT.XFE_E.XP.n59 5.32067
R6689 XFRONT.XFE_E.XP.n58 XFRONT.XFE_E.XP.n57 5.32067
R6690 XFRONT.XFE_E.XP.n68 XFRONT.XFE_E.XP.n67 5.32067
R6691 XFRONT.XFE_E.XP XFRONT.XFE_E.XP.n28 4.53963
R6692 XFRONT.XFE_E.XP.n80 XFRONT.XFE_E.XP.n79 4.5005
R6693 XFRONT.XFE_E.XP.n23 XFRONT.XFE_E.XP.n22 4.42851
R6694 XFRONT.XFE_E.XP.n6 XFRONT.XFE_E.XP.n5 4.42851
R6695 XFRONT.XFE_E.XP.n52 XFRONT.XFE_E.XP.n51 4.42851
R6696 XFRONT.XFE_E.XP.n42 XFRONT.XFE_E.XP.n41 4.42851
R6697 XFRONT.XFE_E.XP.n28 XFRONT.XFE_E.XP.n27 2.48193
R6698 XFRONT.XFE_E.XP.n80 XFRONT.XFE_E.XP.n69 2.38746
R6699 XFRONT.XFE_E.XP.n69 XFRONT.XFE_E.XP.n62 1.72224
R6700 XFRONT.XFE_E.XP XFRONT.XFE_E.XP.n80 1.56572
R6701 XFRONT.XFE_E.XP.n63 XFRONT.XFE_E.XP.t10 0.228
R6702 XFRONT.XFE_E.XP.n63 XFRONT.XFE_E.XP.t11 0.228
R6703 XFRONT.XFE_E.XP.n65 XFRONT.XFE_E.XP.t8 0.228
R6704 XFRONT.XFE_E.XP.n65 XFRONT.XFE_E.XP.t9 0.228
R6705 XFRONT.XFE_E.XP.n74 XFRONT.XFE_E.XP.t27 0.228
R6706 XFRONT.XFE_E.XP.n74 XFRONT.XFE_E.XP.t30 0.228
R6707 XFRONT.XFE_E.XP.n72 XFRONT.XFE_E.XP.t33 0.228
R6708 XFRONT.XFE_E.XP.n72 XFRONT.XFE_E.XP.t28 0.228
R6709 XFRONT.XFE_E.XP.n70 XFRONT.XFE_E.XP.t25 0.228
R6710 XFRONT.XFE_E.XP.n70 XFRONT.XFE_E.XP.t34 0.228
R6711 XFRONT.XFE_E.XP.n56 XFRONT.XFE_E.XP.t19 0.228
R6712 XFRONT.XFE_E.XP.n56 XFRONT.XFE_E.XP.t20 0.228
R6713 XFRONT.XFE_E.XP.n59 XFRONT.XFE_E.XP.t17 0.228
R6714 XFRONT.XFE_E.XP.n59 XFRONT.XFE_E.XP.t18 0.228
R6715 XFRONT.XFE_E.XP.n57 XFRONT.XFE_E.XP.t15 0.228
R6716 XFRONT.XFE_E.XP.n57 XFRONT.XFE_E.XP.t16 0.228
R6717 XFRONT.XFE_E.XP.n67 XFRONT.XFE_E.XP.t6 0.228
R6718 XFRONT.XFE_E.XP.n67 XFRONT.XFE_E.XP.t7 0.228
R6719 XFRONT.XFE_E.XP.n14 XFRONT.XFE_E.XP.t1 0.20525
R6720 XFRONT.XFE_E.XP.n14 XFRONT.XFE_E.XP.t2 0.20525
R6721 XFRONT.XFE_E.XP.n18 XFRONT.XFE_E.XP.t31 0.20525
R6722 XFRONT.XFE_E.XP.n18 XFRONT.XFE_E.XP.t0 0.20525
R6723 XFRONT.XFE_E.XP.n16 XFRONT.XFE_E.XP.t4 0.20525
R6724 XFRONT.XFE_E.XP.n16 XFRONT.XFE_E.XP.t32 0.20525
R6725 XFRONT.XFE_E.XP.n77 XFRONT.XFE_E.XP.t24 0.20525
R6726 XFRONT.XFE_E.XP.n77 XFRONT.XFE_E.XP.t23 0.20525
R6727 XFRONT.XFE_E.XP.n68 XFRONT.XFE_E.XP.n66 0.189974
R6728 XFRONT.XFE_E.XP.n66 XFRONT.XFE_E.XP.n64 0.189974
R6729 XFRONT.XFE_E.XP.n19 XFRONT.XFE_E.XP.n17 0.189974
R6730 XFRONT.XFE_E.XP.n73 XFRONT.XFE_E.XP.n71 0.189974
R6731 XFRONT.XFE_E.XP.n75 XFRONT.XFE_E.XP.n73 0.189974
R6732 XFRONT.XFE_E.XP.n76 XFRONT.XFE_E.XP.n75 0.189974
R6733 XFRONT.XFE_E.XP.n60 XFRONT.XFE_E.XP.n58 0.189974
R6734 XFRONT.XFE_E.XP.n61 XFRONT.XFE_E.XP.n60 0.189974
R6735 XFRONT.XFE_E.XP.n26 XFRONT.XFE_E.XP.n21 0.1205
R6736 XFRONT.XFE_E.XP.n4 XFRONT.XFE_E.XP.n3 0.1205
R6737 XFRONT.XFE_E.XP.n3 XFRONT.XFE_E.XP.n2 0.1205
R6738 XFRONT.XFE_E.XP.n2 XFRONT.XFE_E.XP.n1 0.1205
R6739 XFRONT.XFE_E.XP.n1 XFRONT.XFE_E.XP.n0 0.1205
R6740 XFRONT.XFE_E.XP.n13 XFRONT.XFE_E.XP.n0 0.1205
R6741 XFRONT.XFE_E.XP.n49 XFRONT.XFE_E.XP.n30 0.1205
R6742 XFRONT.XFE_E.XP.n31 XFRONT.XFE_E.XP.n30 0.1205
R6743 XFRONT.XFE_E.XP.n32 XFRONT.XFE_E.XP.n31 0.1205
R6744 XFRONT.XFE_E.XP.n33 XFRONT.XFE_E.XP.n32 0.1205
R6745 XFRONT.XFE_E.XP.n34 XFRONT.XFE_E.XP.n33 0.1205
R6746 XFRONT.XFE_E.XP.n35 XFRONT.XFE_E.XP.n29 0.1205
R6747 XFRONT.XFE_E.XP.n36 XFRONT.XFE_E.XP.n35 0.1205
R6748 XFRONT.XFE_E.XP.n37 XFRONT.XFE_E.XP.n36 0.1205
R6749 XFRONT.XFE_E.XP.n38 XFRONT.XFE_E.XP.n37 0.1205
R6750 XFRONT.XFE_E.XP.n39 XFRONT.XFE_E.XP.n38 0.1205
R6751 XFRONT.XFE_E.XP.n40 XFRONT.XFE_E.XP.n39 0.1205
R6752 XFRONT.XFE_E.XP.n20 XFRONT.XFE_E.XP.n19 0.0952368
R6753 XFRONT.XFE_E.XP.n20 XFRONT.XFE_E.XP.n15 0.0952368
R6754 XFRONT.XFE_E.XN.t57 XFRONT.XFE_E.XN.n12 127.788
R6755 XFRONT.XFE_E.XN.n5 XFRONT.XFE_E.XN.t50 127.788
R6756 XFRONT.XFE_E.XN.t52 XFRONT.XFE_E.XN.n6 127.668
R6757 XFRONT.XFE_E.XN.n12 XFRONT.XFE_E.XN.t56 127.668
R6758 XFRONT.XFE_E.XN.n11 XFRONT.XFE_E.XN.t55 127.668
R6759 XFRONT.XFE_E.XN.n10 XFRONT.XFE_E.XN.t54 127.668
R6760 XFRONT.XFE_E.XN.n9 XFRONT.XFE_E.XN.t53 127.668
R6761 XFRONT.XFE_E.XN.n5 XFRONT.XFE_E.XN.t51 127.668
R6762 XFRONT.XFE_E.XN.n21 XFRONT.XFE_E.XN.t35 113.632
R6763 XFRONT.XFE_E.XN.n13 XFRONT.XFE_E.XN.t57 113.632
R6764 XFRONT.XFE_E.XN.t50 XFRONT.XFE_E.XN.n4 113.632
R6765 XFRONT.XFE_E.XN.n48 XFRONT.XFE_E.XN.t38 113.632
R6766 XFRONT.XFE_E.XN.n29 XFRONT.XFE_E.XN.t42 113.632
R6767 XFRONT.XFE_E.XN.n23 XFRONT.XFE_E.XN.t37 109.174
R6768 XFRONT.XFE_E.XN.n22 XFRONT.XFE_E.XN.t36 109.174
R6769 XFRONT.XFE_E.XN.n7 XFRONT.XFE_E.XN.t52 109.174
R6770 XFRONT.XFE_E.XN.t56 XFRONT.XFE_E.XN.n8 109.174
R6771 XFRONT.XFE_E.XN.n15 XFRONT.XFE_E.XN.t55 109.174
R6772 XFRONT.XFE_E.XN.n16 XFRONT.XFE_E.XN.t54 109.174
R6773 XFRONT.XFE_E.XN.n17 XFRONT.XFE_E.XN.t53 109.174
R6774 XFRONT.XFE_E.XN.t51 XFRONT.XFE_E.XN.n3 109.174
R6775 XFRONT.XFE_E.XN.n51 XFRONT.XFE_E.XN.t41 109.174
R6776 XFRONT.XFE_E.XN.n50 XFRONT.XFE_E.XN.t40 109.174
R6777 XFRONT.XFE_E.XN.n49 XFRONT.XFE_E.XN.t39 109.174
R6778 XFRONT.XFE_E.XN.n36 XFRONT.XFE_E.XN.t47 109.174
R6779 XFRONT.XFE_E.XN.n37 XFRONT.XFE_E.XN.t48 109.174
R6780 XFRONT.XFE_E.XN.n38 XFRONT.XFE_E.XN.t49 109.174
R6781 XFRONT.XFE_E.XN.n27 XFRONT.XFE_E.XN.t46 109.174
R6782 XFRONT.XFE_E.XN.n32 XFRONT.XFE_E.XN.t45 109.174
R6783 XFRONT.XFE_E.XN.n31 XFRONT.XFE_E.XN.t44 109.174
R6784 XFRONT.XFE_E.XN.n30 XFRONT.XFE_E.XN.t43 109.174
R6785 XFRONT.XFE_E.XN.n72 XFRONT.XFE_E.XN.n71 21.0284
R6786 XFRONT.XFE_E.XN.n80 XFRONT.XFE_E.XN.n79 18.9712
R6787 XFRONT.XFE_E.XN.n39 XFRONT.XFE_E.XN.n38 18.5723
R6788 XFRONT.XFE_E.XN.n24 XFRONT.XFE_E.XN.n23 18.4942
R6789 XFRONT.XFE_E.XN.n7 XFRONT.XFE_E.XN.n1 18.4942
R6790 XFRONT.XFE_E.XN.n15 XFRONT.XFE_E.XN.n14 18.4942
R6791 XFRONT.XFE_E.XN.n16 XFRONT.XFE_E.XN.n2 18.4942
R6792 XFRONT.XFE_E.XN.n18 XFRONT.XFE_E.XN.n17 18.4942
R6793 XFRONT.XFE_E.XN.n52 XFRONT.XFE_E.XN.n51 18.4942
R6794 XFRONT.XFE_E.XN.n50 XFRONT.XFE_E.XN.n47 18.4942
R6795 XFRONT.XFE_E.XN.n36 XFRONT.XFE_E.XN.n35 18.4942
R6796 XFRONT.XFE_E.XN.n37 XFRONT.XFE_E.XN.n26 18.4942
R6797 XFRONT.XFE_E.XN.n34 XFRONT.XFE_E.XN.n27 18.4942
R6798 XFRONT.XFE_E.XN.n33 XFRONT.XFE_E.XN.n32 18.4942
R6799 XFRONT.XFE_E.XN.n31 XFRONT.XFE_E.XN.n28 18.4942
R6800 XFRONT.XFE_E.XN.n25 XFRONT.XFE_E.XN.n24 16.6599
R6801 XFRONT.XFE_E.XN.n64 XFRONT.XFE_E.XN.n61 12.6712
R6802 XFRONT.XFE_E.XN.n23 XFRONT.XFE_E.XN.n22 11.6805
R6803 XFRONT.XFE_E.XN.n16 XFRONT.XFE_E.XN.n15 11.6805
R6804 XFRONT.XFE_E.XN.n15 XFRONT.XFE_E.XN.n8 11.6805
R6805 XFRONT.XFE_E.XN.n17 XFRONT.XFE_E.XN.n16 11.6805
R6806 XFRONT.XFE_E.XN.n17 XFRONT.XFE_E.XN.n7 11.6805
R6807 XFRONT.XFE_E.XN.n7 XFRONT.XFE_E.XN.n3 11.6805
R6808 XFRONT.XFE_E.XN.n51 XFRONT.XFE_E.XN.n50 11.6805
R6809 XFRONT.XFE_E.XN.n50 XFRONT.XFE_E.XN.n49 11.6805
R6810 XFRONT.XFE_E.XN.n36 XFRONT.XFE_E.XN.n27 11.6805
R6811 XFRONT.XFE_E.XN.n37 XFRONT.XFE_E.XN.n36 11.6805
R6812 XFRONT.XFE_E.XN.n38 XFRONT.XFE_E.XN.n37 11.6805
R6813 XFRONT.XFE_E.XN.n32 XFRONT.XFE_E.XN.n27 11.6805
R6814 XFRONT.XFE_E.XN.n32 XFRONT.XFE_E.XN.n31 11.6805
R6815 XFRONT.XFE_E.XN.n31 XFRONT.XFE_E.XN.n30 11.6805
R6816 XFRONT.XFE_E.XN.n20 XFRONT.XFE_E.XN.n0 10.8396
R6817 XFRONT.XFE_E.XN.n54 XFRONT.XFE_E.XN.n39 10.7748
R6818 XFRONT.XFE_E.XN.n64 XFRONT.XFE_E.XN.n63 9.44001
R6819 XFRONT.XFE_E.XN.n53 XFRONT.XFE_E.XN.n52 9.1385
R6820 XFRONT.XFE_E.XN.n20 XFRONT.XFE_E.XN.n19 9.0005
R6821 XFRONT.XFE_E.XN.n24 XFRONT.XFE_E.XN.n21 7.17687
R6822 XFRONT.XFE_E.XN.n14 XFRONT.XFE_E.XN.n13 7.17687
R6823 XFRONT.XFE_E.XN.n4 XFRONT.XFE_E.XN.n1 7.17687
R6824 XFRONT.XFE_E.XN.n48 XFRONT.XFE_E.XN.n47 7.17687
R6825 XFRONT.XFE_E.XN.n29 XFRONT.XFE_E.XN.n28 7.17687
R6826 XFRONT.XFE_E.XN.n65 XFRONT.XFE_E.XN.n54 6.41789
R6827 XFRONT.XFE_E.XN.n53 XFRONT.XFE_E.XN.n46 6.40336
R6828 XFRONT.XFE_E.XN.n41 XFRONT.XFE_E.XN.t1 5.7796
R6829 XFRONT.XFE_E.XN.n43 XFRONT.XFE_E.XN.t0 5.7796
R6830 XFRONT.XFE_E.XN.n71 XFRONT.XFE_E.XN.t13 5.73764
R6831 XFRONT.XFE_E.XN.n56 XFRONT.XFE_E.XN.t29 5.73764
R6832 XFRONT.XFE_E.XN.n60 XFRONT.XFE_E.XN.t28 5.73764
R6833 XFRONT.XFE_E.XN.n67 XFRONT.XFE_E.XN.t6 5.73764
R6834 XFRONT.XFE_E.XN.n25 XFRONT.XFE_E.XN.n20 5.63193
R6835 XFRONT.XFE_E.XN.n63 XFRONT.XFE_E.XN.t32 5.59012
R6836 XFRONT.XFE_E.XN.n63 XFRONT.XFE_E.XN.n62 5.57485
R6837 XFRONT.XFE_E.XN.n75 XFRONT.XFE_E.XN.n73 5.51014
R6838 XFRONT.XFE_E.XN.n79 XFRONT.XFE_E.XN.n78 5.4154
R6839 XFRONT.XFE_E.XN.n41 XFRONT.XFE_E.XN.n40 5.38537
R6840 XFRONT.XFE_E.XN.n45 XFRONT.XFE_E.XN.n44 5.38537
R6841 XFRONT.XFE_E.XN.n43 XFRONT.XFE_E.XN.n42 5.38537
R6842 XFRONT.XFE_E.XN.n75 XFRONT.XFE_E.XN.n74 5.32067
R6843 XFRONT.XFE_E.XN.n77 XFRONT.XFE_E.XN.n76 5.32067
R6844 XFRONT.XFE_E.XN.n56 XFRONT.XFE_E.XN.n55 5.32067
R6845 XFRONT.XFE_E.XN.n58 XFRONT.XFE_E.XN.n57 5.32067
R6846 XFRONT.XFE_E.XN.n60 XFRONT.XFE_E.XN.n59 5.32067
R6847 XFRONT.XFE_E.XN.n71 XFRONT.XFE_E.XN.n70 5.32067
R6848 XFRONT.XFE_E.XN.n69 XFRONT.XFE_E.XN.n68 5.32067
R6849 XFRONT.XFE_E.XN.n67 XFRONT.XFE_E.XN.n66 5.32067
R6850 XFRONT.XFE_E.XN XFRONT.XFE_E.XN.n25 4.53963
R6851 XFRONT.XFE_E.XN.n65 XFRONT.XFE_E.XN.n64 4.5005
R6852 XFRONT.XFE_E.XN.n22 XFRONT.XFE_E.XN.n21 4.42851
R6853 XFRONT.XFE_E.XN.n13 XFRONT.XFE_E.XN.n8 4.42851
R6854 XFRONT.XFE_E.XN.n4 XFRONT.XFE_E.XN.n3 4.42851
R6855 XFRONT.XFE_E.XN.n49 XFRONT.XFE_E.XN.n48 4.42851
R6856 XFRONT.XFE_E.XN.n30 XFRONT.XFE_E.XN.n29 4.42851
R6857 XFRONT.XFE_E.XN XFRONT.XFE_E.XN.n80 3.91354
R6858 XFRONT.XFE_E.XN.n54 XFRONT.XFE_E.XN.n53 2.93193
R6859 XFRONT.XFE_E.XN.n72 XFRONT.XFE_E.XN.n65 1.76137
R6860 XFRONT.XFE_E.XN.n80 XFRONT.XFE_E.XN.n72 1.72224
R6861 XFRONT.XFE_E.XN.n73 XFRONT.XFE_E.XN.t20 0.228
R6862 XFRONT.XFE_E.XN.n73 XFRONT.XFE_E.XN.t21 0.228
R6863 XFRONT.XFE_E.XN.n74 XFRONT.XFE_E.XN.t18 0.228
R6864 XFRONT.XFE_E.XN.n74 XFRONT.XFE_E.XN.t19 0.228
R6865 XFRONT.XFE_E.XN.n76 XFRONT.XFE_E.XN.t16 0.228
R6866 XFRONT.XFE_E.XN.n76 XFRONT.XFE_E.XN.t17 0.228
R6867 XFRONT.XFE_E.XN.n78 XFRONT.XFE_E.XN.t14 0.228
R6868 XFRONT.XFE_E.XN.n78 XFRONT.XFE_E.XN.t15 0.228
R6869 XFRONT.XFE_E.XN.n55 XFRONT.XFE_E.XN.t23 0.228
R6870 XFRONT.XFE_E.XN.n55 XFRONT.XFE_E.XN.t24 0.228
R6871 XFRONT.XFE_E.XN.n57 XFRONT.XFE_E.XN.t27 0.228
R6872 XFRONT.XFE_E.XN.n57 XFRONT.XFE_E.XN.t22 0.228
R6873 XFRONT.XFE_E.XN.n59 XFRONT.XFE_E.XN.t25 0.228
R6874 XFRONT.XFE_E.XN.n59 XFRONT.XFE_E.XN.t26 0.228
R6875 XFRONT.XFE_E.XN.n70 XFRONT.XFE_E.XN.t11 0.228
R6876 XFRONT.XFE_E.XN.n70 XFRONT.XFE_E.XN.t12 0.228
R6877 XFRONT.XFE_E.XN.n68 XFRONT.XFE_E.XN.t9 0.228
R6878 XFRONT.XFE_E.XN.n68 XFRONT.XFE_E.XN.t10 0.228
R6879 XFRONT.XFE_E.XN.n66 XFRONT.XFE_E.XN.t7 0.228
R6880 XFRONT.XFE_E.XN.n66 XFRONT.XFE_E.XN.t8 0.228
R6881 XFRONT.XFE_E.XN.n40 XFRONT.XFE_E.XN.t2 0.20525
R6882 XFRONT.XFE_E.XN.n40 XFRONT.XFE_E.XN.t4 0.20525
R6883 XFRONT.XFE_E.XN.n44 XFRONT.XFE_E.XN.t5 0.20525
R6884 XFRONT.XFE_E.XN.n44 XFRONT.XFE_E.XN.t33 0.20525
R6885 XFRONT.XFE_E.XN.n42 XFRONT.XFE_E.XN.t3 0.20525
R6886 XFRONT.XFE_E.XN.n42 XFRONT.XFE_E.XN.t34 0.20525
R6887 XFRONT.XFE_E.XN.n62 XFRONT.XFE_E.XN.t30 0.20525
R6888 XFRONT.XFE_E.XN.n62 XFRONT.XFE_E.XN.t31 0.20525
R6889 XFRONT.XFE_E.XN.n69 XFRONT.XFE_E.XN.n67 0.189974
R6890 XFRONT.XFE_E.XN.n71 XFRONT.XFE_E.XN.n69 0.189974
R6891 XFRONT.XFE_E.XN.n77 XFRONT.XFE_E.XN.n75 0.189974
R6892 XFRONT.XFE_E.XN.n45 XFRONT.XFE_E.XN.n43 0.189974
R6893 XFRONT.XFE_E.XN.n58 XFRONT.XFE_E.XN.n56 0.189974
R6894 XFRONT.XFE_E.XN.n61 XFRONT.XFE_E.XN.n58 0.166289
R6895 XFRONT.XFE_E.XN.n6 XFRONT.XFE_E.XN.n5 0.1205
R6896 XFRONT.XFE_E.XN.n12 XFRONT.XFE_E.XN.n11 0.1205
R6897 XFRONT.XFE_E.XN.n11 XFRONT.XFE_E.XN.n10 0.1205
R6898 XFRONT.XFE_E.XN.n14 XFRONT.XFE_E.XN.n2 0.1205
R6899 XFRONT.XFE_E.XN.n52 XFRONT.XFE_E.XN.n47 0.1205
R6900 XFRONT.XFE_E.XN.n35 XFRONT.XFE_E.XN.n34 0.1205
R6901 XFRONT.XFE_E.XN.n34 XFRONT.XFE_E.XN.n33 0.1205
R6902 XFRONT.XFE_E.XN.n33 XFRONT.XFE_E.XN.n28 0.1205
R6903 XFRONT.XFE_E.XN.n10 XFRONT.XFE_E.XN.n9 0.114816
R6904 XFRONT.XFE_E.XN.n18 XFRONT.XFE_E.XN.n2 0.114816
R6905 XFRONT.XFE_E.XN.n35 XFRONT.XFE_E.XN.n26 0.114816
R6906 XFRONT.XFE_E.XN.n79 XFRONT.XFE_E.XN.n77 0.0952368
R6907 XFRONT.XFE_E.XN.n46 XFRONT.XFE_E.XN.n45 0.0952368
R6908 XFRONT.XFE_E.XN.n46 XFRONT.XFE_E.XN.n41 0.0952368
R6909 XFRONT.XFE_E.XN.n19 XFRONT.XFE_E.XN.n1 0.0785
R6910 XFRONT.XFE_E.XN.n6 XFRONT.XFE_E.XN.n0 0.0785
R6911 XFRONT.XFE_E.XN.n19 XFRONT.XFE_E.XN.n18 0.0241842
R6912 XFRONT.XFE_E.XN.n9 XFRONT.XFE_E.XN.n0 0.0241842
R6913 XFRONT.XFE_E.XN.n39 XFRONT.XFE_E.XN.n26 0.0241842
R6914 XFRONT.XFE_E.XN.n61 XFRONT.XFE_E.XN.n60 0.0241842
R6915 XFRONT.XFE_O.VREGN.n14 XFRONT.XFE_O.VREGN.n6 11.1284
R6916 XFRONT.XFE_O.VREGN.n14 XFRONT.XFE_O.VREGN.n13 8.37084
R6917 XFRONT.XFE_O.VREGN.n1 XFRONT.XFE_O.VREGN.t15 5.73764
R6918 XFRONT.XFE_O.VREGN.n3 XFRONT.XFE_O.VREGN.t8 5.73764
R6919 XFRONT.XFE_O.VREGN.n9 XFRONT.XFE_O.VREGN.n7 5.51014
R6920 XFRONT.XFE_O.VREGN.n13 XFRONT.XFE_O.VREGN.n12 5.32067
R6921 XFRONT.XFE_O.VREGN.n1 XFRONT.XFE_O.VREGN.n0 5.32067
R6922 XFRONT.XFE_O.VREGN.n5 XFRONT.XFE_O.VREGN.n4 5.32067
R6923 XFRONT.XFE_O.VREGN.n3 XFRONT.XFE_O.VREGN.n2 5.32067
R6924 XFRONT.XFE_O.VREGN.n11 XFRONT.XFE_O.VREGN.n10 5.32067
R6925 XFRONT.XFE_O.VREGN.n9 XFRONT.XFE_O.VREGN.n8 5.32067
R6926 XFRONT.XFE_O.VREGN XFRONT.XFE_O.VREGN.n14 4.53963
R6927 XFRONT.XFE_O.VREGN.n12 XFRONT.XFE_O.VREGN.t6 0.228
R6928 XFRONT.XFE_O.VREGN.n12 XFRONT.XFE_O.VREGN.t7 0.228
R6929 XFRONT.XFE_O.VREGN.n0 XFRONT.XFE_O.VREGN.t13 0.228
R6930 XFRONT.XFE_O.VREGN.n0 XFRONT.XFE_O.VREGN.t14 0.228
R6931 XFRONT.XFE_O.VREGN.n4 XFRONT.XFE_O.VREGN.t11 0.228
R6932 XFRONT.XFE_O.VREGN.n4 XFRONT.XFE_O.VREGN.t12 0.228
R6933 XFRONT.XFE_O.VREGN.n2 XFRONT.XFE_O.VREGN.t9 0.228
R6934 XFRONT.XFE_O.VREGN.n2 XFRONT.XFE_O.VREGN.t10 0.228
R6935 XFRONT.XFE_O.VREGN.n10 XFRONT.XFE_O.VREGN.t4 0.228
R6936 XFRONT.XFE_O.VREGN.n10 XFRONT.XFE_O.VREGN.t5 0.228
R6937 XFRONT.XFE_O.VREGN.n8 XFRONT.XFE_O.VREGN.t2 0.228
R6938 XFRONT.XFE_O.VREGN.n8 XFRONT.XFE_O.VREGN.t3 0.228
R6939 XFRONT.XFE_O.VREGN.n7 XFRONT.XFE_O.VREGN.t0 0.228
R6940 XFRONT.XFE_O.VREGN.n7 XFRONT.XFE_O.VREGN.t1 0.228
R6941 XFRONT.XFE_O.VREGN.n11 XFRONT.XFE_O.VREGN.n9 0.189974
R6942 XFRONT.XFE_O.VREGN.n13 XFRONT.XFE_O.VREGN.n11 0.189974
R6943 XFRONT.XFE_O.VREGN.n5 XFRONT.XFE_O.VREGN.n3 0.189974
R6944 XFRONT.XFE_O.VREGN.n6 XFRONT.XFE_O.VREGN.n5 0.0952368
R6945 XFRONT.XFE_O.VREGN.n6 XFRONT.XFE_O.VREGN.n1 0.0952368
R6946 XFRONT.XFE_O.SB.n20 XFRONT.XFE_O.SB.t14 127.788
R6947 XFRONT.XFE_O.SB.n13 XFRONT.XFE_O.SB.t7 127.788
R6948 XFRONT.XFE_O.SB.t10 XFRONT.XFE_O.SB.n15 127.668
R6949 XFRONT.XFE_O.SB.n20 XFRONT.XFE_O.SB.t13 127.668
R6950 XFRONT.XFE_O.SB.t12 XFRONT.XFE_O.SB.n21 127.668
R6951 XFRONT.XFE_O.SB.n18 XFRONT.XFE_O.SB.t11 127.668
R6952 XFRONT.XFE_O.SB.n13 XFRONT.XFE_O.SB.t8 127.668
R6953 XFRONT.XFE_O.SB.n14 XFRONT.XFE_O.SB.t9 127.668
R6954 XFRONT.XFE_O.SB.t14 XFRONT.XFE_O.SB.n19 113.632
R6955 XFRONT.XFE_O.SB.n11 XFRONT.XFE_O.SB.t7 113.632
R6956 XFRONT.XFE_O.SB.n16 XFRONT.XFE_O.SB.t10 109.174
R6957 XFRONT.XFE_O.SB.t13 XFRONT.XFE_O.SB.n17 109.174
R6958 XFRONT.XFE_O.SB.n22 XFRONT.XFE_O.SB.t12 109.174
R6959 XFRONT.XFE_O.SB.n23 XFRONT.XFE_O.SB.t11 109.174
R6960 XFRONT.XFE_O.SB.t8 XFRONT.XFE_O.SB.n12 109.174
R6961 XFRONT.XFE_O.SB.t9 XFRONT.XFE_O.SB.n9 109.174
R6962 XFRONT.XFE_O.SB.n4 XFRONT.XFE_O.SB.t0 24.3193
R6963 XFRONT.XFE_O.SB.n16 XFRONT.XFE_O.SB.n7 18.4942
R6964 XFRONT.XFE_O.SB.n22 XFRONT.XFE_O.SB.n8 18.4942
R6965 XFRONT.XFE_O.SB.n24 XFRONT.XFE_O.SB.n23 18.4942
R6966 XFRONT.XFE_O.SB.n10 XFRONT.XFE_O.SB.n9 18.4942
R6967 XFRONT.XFE_O.SB.n5 XFRONT.XFE_O.SB.n4 16.5284
R6968 XFRONT.XFE_O.SB.n2 XFRONT.XFE_O.SB.n0 13.9299
R6969 XFRONT.XFE_O.SB.n23 XFRONT.XFE_O.SB.n22 11.6805
R6970 XFRONT.XFE_O.SB.n22 XFRONT.XFE_O.SB.n17 11.6805
R6971 XFRONT.XFE_O.SB.n23 XFRONT.XFE_O.SB.n16 11.6805
R6972 XFRONT.XFE_O.SB.n12 XFRONT.XFE_O.SB.n9 11.6805
R6973 XFRONT.XFE_O.SB.n16 XFRONT.XFE_O.SB.n9 11.6805
R6974 XFRONT.XFE_O.SB.n5 XFRONT.XFE_O.SB.n2 11.5728
R6975 XFRONT.XFE_O.SB.n26 XFRONT.XFE_O.SB.n6 10.8396
R6976 XFRONT.XFE_O.SB.n4 XFRONT.XFE_O.SB.n3 10.1049
R6977 XFRONT.XFE_O.SB.n26 XFRONT.XFE_O.SB.n25 9.0005
R6978 XFRONT.XFE_O.SB.n19 XFRONT.XFE_O.SB.n8 7.17687
R6979 XFRONT.XFE_O.SB.n11 XFRONT.XFE_O.SB.n10 7.17687
R6980 XFRONT.XFE_O.SB.n27 XFRONT.XFE_O.SB.n26 6.72479
R6981 XFRONT.XFE_O.SB.n27 XFRONT.XFE_O.SB.n5 6.33963
R6982 XFRONT.XFE_O.SB.n1 XFRONT.XFE_O.SB.t2 5.7796
R6983 XFRONT.XFE_O.SB.n0 XFRONT.XFE_O.SB.t3 5.73764
R6984 XFRONT.XFE_O.SB.n1 XFRONT.XFE_O.SB.t1 5.59012
R6985 XFRONT.XFE_O.SB.n0 XFRONT.XFE_O.SB.t4 5.54817
R6986 XFRONT.XFE_O.SB.n2 XFRONT.XFE_O.SB.n1 4.5005
R6987 XFRONT.XFE_O.SB.n19 XFRONT.XFE_O.SB.n17 4.42851
R6988 XFRONT.XFE_O.SB.n12 XFRONT.XFE_O.SB.n11 4.42851
R6989 XFRONT.XFE_O.SB.n3 XFRONT.XFE_O.SB.t6 0.228
R6990 XFRONT.XFE_O.SB.n3 XFRONT.XFE_O.SB.t5 0.228
R6991 XFRONT.XFE_O.SB.n10 XFRONT.XFE_O.SB.n7 0.1205
R6992 XFRONT.XFE_O.SB.n15 XFRONT.XFE_O.SB.n14 0.1205
R6993 XFRONT.XFE_O.SB.n14 XFRONT.XFE_O.SB.n13 0.1205
R6994 XFRONT.XFE_O.SB.n21 XFRONT.XFE_O.SB.n20 0.1205
R6995 XFRONT.XFE_O.SB.n21 XFRONT.XFE_O.SB.n18 0.1205
R6996 XFRONT.XFE_O.SB.n24 XFRONT.XFE_O.SB.n8 0.1205
R6997 XFRONT.XFE_O.SB.n25 XFRONT.XFE_O.SB.n7 0.0485
R6998 XFRONT.XFE_O.SB.n15 XFRONT.XFE_O.SB.n6 0.0485
R6999 XFRONT.XFE_O.SB.n18 XFRONT.XFE_O.SB.n6 0.0485
R7000 XFRONT.XFE_O.SB.n25 XFRONT.XFE_O.SB.n24 0.0485
R7001 XFRONT.XFE_O.SB XFRONT.XFE_O.SB.n27 0.0396304
R7002 XFRONT.XFE_O.SA.n14 XFRONT.XFE_O.SA.t14 127.788
R7003 XFRONT.XFE_O.SA.n7 XFRONT.XFE_O.SA.t7 127.788
R7004 XFRONT.XFE_O.SA.t10 XFRONT.XFE_O.SA.n9 127.668
R7005 XFRONT.XFE_O.SA.n14 XFRONT.XFE_O.SA.t13 127.668
R7006 XFRONT.XFE_O.SA.t12 XFRONT.XFE_O.SA.n15 127.668
R7007 XFRONT.XFE_O.SA.n12 XFRONT.XFE_O.SA.t11 127.668
R7008 XFRONT.XFE_O.SA.n7 XFRONT.XFE_O.SA.t8 127.668
R7009 XFRONT.XFE_O.SA.n8 XFRONT.XFE_O.SA.t9 127.668
R7010 XFRONT.XFE_O.SA.t14 XFRONT.XFE_O.SA.n13 113.632
R7011 XFRONT.XFE_O.SA.n5 XFRONT.XFE_O.SA.t7 113.632
R7012 XFRONT.XFE_O.SA.n10 XFRONT.XFE_O.SA.t10 109.174
R7013 XFRONT.XFE_O.SA.t13 XFRONT.XFE_O.SA.n11 109.174
R7014 XFRONT.XFE_O.SA.n16 XFRONT.XFE_O.SA.t12 109.174
R7015 XFRONT.XFE_O.SA.n17 XFRONT.XFE_O.SA.t11 109.174
R7016 XFRONT.XFE_O.SA.t8 XFRONT.XFE_O.SA.n6 109.174
R7017 XFRONT.XFE_O.SA.t9 XFRONT.XFE_O.SA.n3 109.174
R7018 XFRONT.XFE_O.SA.n22 XFRONT.XFE_O.SA.t0 22.3095
R7019 XFRONT.XFE_O.SA.n23 XFRONT.XFE_O.SA.n22 19.0355
R7020 XFRONT.XFE_O.SA.n10 XFRONT.XFE_O.SA.n1 18.4942
R7021 XFRONT.XFE_O.SA.n16 XFRONT.XFE_O.SA.n2 18.4942
R7022 XFRONT.XFE_O.SA.n18 XFRONT.XFE_O.SA.n17 18.4942
R7023 XFRONT.XFE_O.SA.n4 XFRONT.XFE_O.SA.n3 18.4942
R7024 XFRONT.XFE_O.SA.n26 XFRONT.XFE_O.SA.n24 14.1193
R7025 XFRONT.XFE_O.SA.n23 XFRONT.XFE_O.SA.n20 13.5922
R7026 XFRONT.XFE_O.SA.n17 XFRONT.XFE_O.SA.n16 11.6805
R7027 XFRONT.XFE_O.SA.n16 XFRONT.XFE_O.SA.n11 11.6805
R7028 XFRONT.XFE_O.SA.n17 XFRONT.XFE_O.SA.n10 11.6805
R7029 XFRONT.XFE_O.SA.n6 XFRONT.XFE_O.SA.n3 11.6805
R7030 XFRONT.XFE_O.SA.n10 XFRONT.XFE_O.SA.n3 11.6805
R7031 XFRONT.XFE_O.SA.n20 XFRONT.XFE_O.SA.n0 10.8396
R7032 XFRONT.XFE_O.SA.n27 XFRONT.XFE_O.SA.n26 9.71407
R7033 XFRONT.XFE_O.SA.n20 XFRONT.XFE_O.SA.n19 9.0005
R7034 XFRONT.XFE_O.SA.n13 XFRONT.XFE_O.SA.n2 7.17687
R7035 XFRONT.XFE_O.SA.n5 XFRONT.XFE_O.SA.n4 7.17687
R7036 XFRONT.XFE_O.SA.n25 XFRONT.XFE_O.SA.t2 5.7796
R7037 XFRONT.XFE_O.SA.n21 XFRONT.XFE_O.SA.t6 5.73764
R7038 XFRONT.XFE_O.SA.n24 XFRONT.XFE_O.SA.t4 5.73764
R7039 XFRONT.XFE_O.SA.n25 XFRONT.XFE_O.SA.t1 5.59012
R7040 XFRONT.XFE_O.SA.n21 XFRONT.XFE_O.SA.t5 5.54817
R7041 XFRONT.XFE_O.SA.n24 XFRONT.XFE_O.SA.t3 5.54817
R7042 XFRONT.XFE_O.SA.n22 XFRONT.XFE_O.SA.n21 4.73734
R7043 XFRONT.XFE_O.SA.n26 XFRONT.XFE_O.SA.n25 4.5005
R7044 XFRONT.XFE_O.SA.n13 XFRONT.XFE_O.SA.n11 4.42851
R7045 XFRONT.XFE_O.SA.n6 XFRONT.XFE_O.SA.n5 4.42851
R7046 XFRONT.XFE_O.SA.n27 XFRONT.XFE_O.SA.n23 2.54398
R7047 XFRONT.XFE_O.SA.n4 XFRONT.XFE_O.SA.n1 0.1205
R7048 XFRONT.XFE_O.SA.n9 XFRONT.XFE_O.SA.n8 0.1205
R7049 XFRONT.XFE_O.SA.n8 XFRONT.XFE_O.SA.n7 0.1205
R7050 XFRONT.XFE_O.SA.n15 XFRONT.XFE_O.SA.n14 0.1205
R7051 XFRONT.XFE_O.SA.n15 XFRONT.XFE_O.SA.n12 0.1205
R7052 XFRONT.XFE_O.SA.n18 XFRONT.XFE_O.SA.n2 0.1205
R7053 XFRONT.XFE_O.SA.n19 XFRONT.XFE_O.SA.n1 0.0485
R7054 XFRONT.XFE_O.SA.n9 XFRONT.XFE_O.SA.n0 0.0485
R7055 XFRONT.XFE_O.SA.n12 XFRONT.XFE_O.SA.n0 0.0485
R7056 XFRONT.XFE_O.SA.n19 XFRONT.XFE_O.SA.n18 0.0485
R7057 XFRONT.XFE_O.SA XFRONT.XFE_O.SA.n27 0.0396304
R7058 XFRONT.XFE_O.VREGP.n14 XFRONT.XFE_O.VREGP.n6 16.4697
R7059 XFRONT.XFE_O.VREGP.n14 XFRONT.XFE_O.VREGP.n13 12.6577
R7060 XFRONT.XFE_O.VREGP.n1 XFRONT.XFE_O.VREGP.t7 5.73764
R7061 XFRONT.XFE_O.VREGP.n5 XFRONT.XFE_O.VREGP.t0 5.73764
R7062 XFRONT.XFE_O.VREGP.n9 XFRONT.XFE_O.VREGP.n7 5.51014
R7063 XFRONT.XFE_O.VREGP.n9 XFRONT.XFE_O.VREGP.n8 5.32067
R7064 XFRONT.XFE_O.VREGP.n11 XFRONT.XFE_O.VREGP.n10 5.32067
R7065 XFRONT.XFE_O.VREGP.n13 XFRONT.XFE_O.VREGP.n12 5.32067
R7066 XFRONT.XFE_O.VREGP.n1 XFRONT.XFE_O.VREGP.n0 5.32067
R7067 XFRONT.XFE_O.VREGP.n3 XFRONT.XFE_O.VREGP.n2 5.32067
R7068 XFRONT.XFE_O.VREGP.n5 XFRONT.XFE_O.VREGP.n4 5.32067
R7069 XFRONT.XFE_O.VREGP.n7 XFRONT.XFE_O.VREGP.t14 0.228
R7070 XFRONT.XFE_O.VREGP.n7 XFRONT.XFE_O.VREGP.t15 0.228
R7071 XFRONT.XFE_O.VREGP.n8 XFRONT.XFE_O.VREGP.t12 0.228
R7072 XFRONT.XFE_O.VREGP.n8 XFRONT.XFE_O.VREGP.t13 0.228
R7073 XFRONT.XFE_O.VREGP.n10 XFRONT.XFE_O.VREGP.t10 0.228
R7074 XFRONT.XFE_O.VREGP.n10 XFRONT.XFE_O.VREGP.t11 0.228
R7075 XFRONT.XFE_O.VREGP.n12 XFRONT.XFE_O.VREGP.t8 0.228
R7076 XFRONT.XFE_O.VREGP.n12 XFRONT.XFE_O.VREGP.t9 0.228
R7077 XFRONT.XFE_O.VREGP.n0 XFRONT.XFE_O.VREGP.t5 0.228
R7078 XFRONT.XFE_O.VREGP.n0 XFRONT.XFE_O.VREGP.t6 0.228
R7079 XFRONT.XFE_O.VREGP.n2 XFRONT.XFE_O.VREGP.t3 0.228
R7080 XFRONT.XFE_O.VREGP.n2 XFRONT.XFE_O.VREGP.t4 0.228
R7081 XFRONT.XFE_O.VREGP.n4 XFRONT.XFE_O.VREGP.t1 0.228
R7082 XFRONT.XFE_O.VREGP.n4 XFRONT.XFE_O.VREGP.t2 0.228
R7083 XFRONT.XFE_O.VREGP.n3 XFRONT.XFE_O.VREGP.n1 0.189974
R7084 XFRONT.XFE_O.VREGP.n13 XFRONT.XFE_O.VREGP.n11 0.189974
R7085 XFRONT.XFE_O.VREGP.n11 XFRONT.XFE_O.VREGP.n9 0.189974
R7086 XFRONT.XFE_O.VREGP.n6 XFRONT.XFE_O.VREGP.n5 0.0952368
R7087 XFRONT.XFE_O.VREGP.n6 XFRONT.XFE_O.VREGP.n3 0.0952368
R7088 XFRONT.XFE_O.VREGP XFRONT.XFE_O.VREGP.n14 0.0396304
R7089 XFRONT.XFE_E.VREGP XFRONT.XFE_E.VREGP.n13 16.4305
R7090 XFRONT.XFE_E.VREGP XFRONT.XFE_E.VREGP.n6 12.6968
R7091 XFRONT.XFE_E.VREGP.n8 XFRONT.XFE_E.VREGP.t7 5.73764
R7092 XFRONT.XFE_E.VREGP.n10 XFRONT.XFE_E.VREGP.t0 5.73764
R7093 XFRONT.XFE_E.VREGP.n2 XFRONT.XFE_E.VREGP.n0 5.51014
R7094 XFRONT.XFE_E.VREGP.n6 XFRONT.XFE_E.VREGP.n5 5.32067
R7095 XFRONT.XFE_E.VREGP.n4 XFRONT.XFE_E.VREGP.n3 5.32067
R7096 XFRONT.XFE_E.VREGP.n2 XFRONT.XFE_E.VREGP.n1 5.32067
R7097 XFRONT.XFE_E.VREGP.n8 XFRONT.XFE_E.VREGP.n7 5.32067
R7098 XFRONT.XFE_E.VREGP.n12 XFRONT.XFE_E.VREGP.n11 5.32067
R7099 XFRONT.XFE_E.VREGP.n10 XFRONT.XFE_E.VREGP.n9 5.32067
R7100 XFRONT.XFE_E.VREGP.n5 XFRONT.XFE_E.VREGP.t14 0.228
R7101 XFRONT.XFE_E.VREGP.n5 XFRONT.XFE_E.VREGP.t15 0.228
R7102 XFRONT.XFE_E.VREGP.n3 XFRONT.XFE_E.VREGP.t12 0.228
R7103 XFRONT.XFE_E.VREGP.n3 XFRONT.XFE_E.VREGP.t13 0.228
R7104 XFRONT.XFE_E.VREGP.n1 XFRONT.XFE_E.VREGP.t10 0.228
R7105 XFRONT.XFE_E.VREGP.n1 XFRONT.XFE_E.VREGP.t11 0.228
R7106 XFRONT.XFE_E.VREGP.n0 XFRONT.XFE_E.VREGP.t8 0.228
R7107 XFRONT.XFE_E.VREGP.n0 XFRONT.XFE_E.VREGP.t9 0.228
R7108 XFRONT.XFE_E.VREGP.n7 XFRONT.XFE_E.VREGP.t5 0.228
R7109 XFRONT.XFE_E.VREGP.n7 XFRONT.XFE_E.VREGP.t6 0.228
R7110 XFRONT.XFE_E.VREGP.n11 XFRONT.XFE_E.VREGP.t3 0.228
R7111 XFRONT.XFE_E.VREGP.n11 XFRONT.XFE_E.VREGP.t4 0.228
R7112 XFRONT.XFE_E.VREGP.n9 XFRONT.XFE_E.VREGP.t1 0.228
R7113 XFRONT.XFE_E.VREGP.n9 XFRONT.XFE_E.VREGP.t2 0.228
R7114 XFRONT.XFE_E.VREGP.n12 XFRONT.XFE_E.VREGP.n10 0.189974
R7115 XFRONT.XFE_E.VREGP.n4 XFRONT.XFE_E.VREGP.n2 0.189974
R7116 XFRONT.XFE_E.VREGP.n6 XFRONT.XFE_E.VREGP.n4 0.189974
R7117 XFRONT.XFE_E.VREGP.n13 XFRONT.XFE_E.VREGP.n12 0.0952368
R7118 XFRONT.XFE_E.VREGP.n13 XFRONT.XFE_E.VREGP.n8 0.0952368
R7119 XFRONT.XFE_E.SA.n17 XFRONT.XFE_E.SA.t14 127.788
R7120 XFRONT.XFE_E.SA.n10 XFRONT.XFE_E.SA.t7 127.788
R7121 XFRONT.XFE_E.SA.t10 XFRONT.XFE_E.SA.n12 127.668
R7122 XFRONT.XFE_E.SA.n17 XFRONT.XFE_E.SA.t13 127.668
R7123 XFRONT.XFE_E.SA.t12 XFRONT.XFE_E.SA.n18 127.668
R7124 XFRONT.XFE_E.SA.n15 XFRONT.XFE_E.SA.t11 127.668
R7125 XFRONT.XFE_E.SA.n10 XFRONT.XFE_E.SA.t8 127.668
R7126 XFRONT.XFE_E.SA.n11 XFRONT.XFE_E.SA.t9 127.668
R7127 XFRONT.XFE_E.SA.t14 XFRONT.XFE_E.SA.n16 113.632
R7128 XFRONT.XFE_E.SA.n8 XFRONT.XFE_E.SA.t7 113.632
R7129 XFRONT.XFE_E.SA.n13 XFRONT.XFE_E.SA.t10 109.174
R7130 XFRONT.XFE_E.SA.t13 XFRONT.XFE_E.SA.n14 109.174
R7131 XFRONT.XFE_E.SA.n19 XFRONT.XFE_E.SA.t12 109.174
R7132 XFRONT.XFE_E.SA.n20 XFRONT.XFE_E.SA.t11 109.174
R7133 XFRONT.XFE_E.SA.t8 XFRONT.XFE_E.SA.n9 109.174
R7134 XFRONT.XFE_E.SA.t9 XFRONT.XFE_E.SA.n6 109.174
R7135 XFRONT.XFE_E.SA.n25 XFRONT.XFE_E.SA.t0 22.3095
R7136 XFRONT.XFE_E.SA.n26 XFRONT.XFE_E.SA.n25 19.0355
R7137 XFRONT.XFE_E.SA.n13 XFRONT.XFE_E.SA.n4 18.4942
R7138 XFRONT.XFE_E.SA.n19 XFRONT.XFE_E.SA.n5 18.4942
R7139 XFRONT.XFE_E.SA.n21 XFRONT.XFE_E.SA.n20 18.4942
R7140 XFRONT.XFE_E.SA.n7 XFRONT.XFE_E.SA.n6 18.4942
R7141 XFRONT.XFE_E.SA.n2 XFRONT.XFE_E.SA.n0 14.1193
R7142 XFRONT.XFE_E.SA.n26 XFRONT.XFE_E.SA.n23 13.5922
R7143 XFRONT.XFE_E.SA.n20 XFRONT.XFE_E.SA.n19 11.6805
R7144 XFRONT.XFE_E.SA.n19 XFRONT.XFE_E.SA.n14 11.6805
R7145 XFRONT.XFE_E.SA.n20 XFRONT.XFE_E.SA.n13 11.6805
R7146 XFRONT.XFE_E.SA.n9 XFRONT.XFE_E.SA.n6 11.6805
R7147 XFRONT.XFE_E.SA.n13 XFRONT.XFE_E.SA.n6 11.6805
R7148 XFRONT.XFE_E.SA.n23 XFRONT.XFE_E.SA.n3 10.8396
R7149 XFRONT.XFE_E.SA XFRONT.XFE_E.SA.n2 9.7532
R7150 XFRONT.XFE_E.SA.n23 XFRONT.XFE_E.SA.n22 9.0005
R7151 XFRONT.XFE_E.SA.n16 XFRONT.XFE_E.SA.n5 7.17687
R7152 XFRONT.XFE_E.SA.n8 XFRONT.XFE_E.SA.n7 7.17687
R7153 XFRONT.XFE_E.SA.n1 XFRONT.XFE_E.SA.t5 5.7796
R7154 XFRONT.XFE_E.SA.n24 XFRONT.XFE_E.SA.t3 5.73764
R7155 XFRONT.XFE_E.SA.n0 XFRONT.XFE_E.SA.t1 5.73764
R7156 XFRONT.XFE_E.SA.n1 XFRONT.XFE_E.SA.t6 5.59012
R7157 XFRONT.XFE_E.SA.n0 XFRONT.XFE_E.SA.t2 5.54817
R7158 XFRONT.XFE_E.SA.n24 XFRONT.XFE_E.SA.t4 5.54817
R7159 XFRONT.XFE_E.SA.n25 XFRONT.XFE_E.SA.n24 4.73734
R7160 XFRONT.XFE_E.SA.n2 XFRONT.XFE_E.SA.n1 4.5005
R7161 XFRONT.XFE_E.SA.n16 XFRONT.XFE_E.SA.n14 4.42851
R7162 XFRONT.XFE_E.SA.n9 XFRONT.XFE_E.SA.n8 4.42851
R7163 XFRONT.XFE_E.SA XFRONT.XFE_E.SA.n26 2.50485
R7164 XFRONT.XFE_E.SA.n7 XFRONT.XFE_E.SA.n4 0.1205
R7165 XFRONT.XFE_E.SA.n12 XFRONT.XFE_E.SA.n11 0.1205
R7166 XFRONT.XFE_E.SA.n11 XFRONT.XFE_E.SA.n10 0.1205
R7167 XFRONT.XFE_E.SA.n18 XFRONT.XFE_E.SA.n17 0.1205
R7168 XFRONT.XFE_E.SA.n18 XFRONT.XFE_E.SA.n15 0.1205
R7169 XFRONT.XFE_E.SA.n21 XFRONT.XFE_E.SA.n5 0.1205
R7170 XFRONT.XFE_E.SA.n22 XFRONT.XFE_E.SA.n4 0.0485
R7171 XFRONT.XFE_E.SA.n12 XFRONT.XFE_E.SA.n3 0.0485
R7172 XFRONT.XFE_E.SA.n15 XFRONT.XFE_E.SA.n3 0.0485
R7173 XFRONT.XFE_E.SA.n22 XFRONT.XFE_E.SA.n21 0.0485
R7174 XFRONT.XFE_E.SB.n14 XFRONT.XFE_E.SB.t14 127.788
R7175 XFRONT.XFE_E.SB.n7 XFRONT.XFE_E.SB.t7 127.788
R7176 XFRONT.XFE_E.SB.t10 XFRONT.XFE_E.SB.n9 127.668
R7177 XFRONT.XFE_E.SB.n14 XFRONT.XFE_E.SB.t13 127.668
R7178 XFRONT.XFE_E.SB.t12 XFRONT.XFE_E.SB.n15 127.668
R7179 XFRONT.XFE_E.SB.n12 XFRONT.XFE_E.SB.t11 127.668
R7180 XFRONT.XFE_E.SB.n7 XFRONT.XFE_E.SB.t8 127.668
R7181 XFRONT.XFE_E.SB.n8 XFRONT.XFE_E.SB.t9 127.668
R7182 XFRONT.XFE_E.SB.t14 XFRONT.XFE_E.SB.n13 113.632
R7183 XFRONT.XFE_E.SB.n5 XFRONT.XFE_E.SB.t7 113.632
R7184 XFRONT.XFE_E.SB.n10 XFRONT.XFE_E.SB.t10 109.174
R7185 XFRONT.XFE_E.SB.t13 XFRONT.XFE_E.SB.n11 109.174
R7186 XFRONT.XFE_E.SB.n16 XFRONT.XFE_E.SB.t12 109.174
R7187 XFRONT.XFE_E.SB.n17 XFRONT.XFE_E.SB.t11 109.174
R7188 XFRONT.XFE_E.SB.t8 XFRONT.XFE_E.SB.n6 109.174
R7189 XFRONT.XFE_E.SB.t9 XFRONT.XFE_E.SB.n3 109.174
R7190 XFRONT.XFE_E.SB.n25 XFRONT.XFE_E.SB.t0 24.3193
R7191 XFRONT.XFE_E.SB.n10 XFRONT.XFE_E.SB.n1 18.4942
R7192 XFRONT.XFE_E.SB.n16 XFRONT.XFE_E.SB.n2 18.4942
R7193 XFRONT.XFE_E.SB.n18 XFRONT.XFE_E.SB.n17 18.4942
R7194 XFRONT.XFE_E.SB.n4 XFRONT.XFE_E.SB.n3 18.4942
R7195 XFRONT.XFE_E.SB.n26 XFRONT.XFE_E.SB.n25 16.5284
R7196 XFRONT.XFE_E.SB.n23 XFRONT.XFE_E.SB.n21 13.9299
R7197 XFRONT.XFE_E.SB.n17 XFRONT.XFE_E.SB.n16 11.6805
R7198 XFRONT.XFE_E.SB.n16 XFRONT.XFE_E.SB.n11 11.6805
R7199 XFRONT.XFE_E.SB.n17 XFRONT.XFE_E.SB.n10 11.6805
R7200 XFRONT.XFE_E.SB.n6 XFRONT.XFE_E.SB.n3 11.6805
R7201 XFRONT.XFE_E.SB.n10 XFRONT.XFE_E.SB.n3 11.6805
R7202 XFRONT.XFE_E.SB.n26 XFRONT.XFE_E.SB.n23 11.5728
R7203 XFRONT.XFE_E.SB.n20 XFRONT.XFE_E.SB.n0 10.8396
R7204 XFRONT.XFE_E.SB.n25 XFRONT.XFE_E.SB.n24 10.1049
R7205 XFRONT.XFE_E.SB.n20 XFRONT.XFE_E.SB.n19 9.0005
R7206 XFRONT.XFE_E.SB.n13 XFRONT.XFE_E.SB.n2 7.17687
R7207 XFRONT.XFE_E.SB.n5 XFRONT.XFE_E.SB.n4 7.17687
R7208 XFRONT.XFE_E.SB XFRONT.XFE_E.SB.n20 6.76392
R7209 XFRONT.XFE_E.SB XFRONT.XFE_E.SB.n26 6.3005
R7210 XFRONT.XFE_E.SB.n22 XFRONT.XFE_E.SB.t5 5.7796
R7211 XFRONT.XFE_E.SB.n21 XFRONT.XFE_E.SB.t2 5.73764
R7212 XFRONT.XFE_E.SB.n22 XFRONT.XFE_E.SB.t6 5.59012
R7213 XFRONT.XFE_E.SB.n21 XFRONT.XFE_E.SB.t1 5.54817
R7214 XFRONT.XFE_E.SB.n23 XFRONT.XFE_E.SB.n22 4.5005
R7215 XFRONT.XFE_E.SB.n13 XFRONT.XFE_E.SB.n11 4.42851
R7216 XFRONT.XFE_E.SB.n6 XFRONT.XFE_E.SB.n5 4.42851
R7217 XFRONT.XFE_E.SB.n24 XFRONT.XFE_E.SB.t3 0.228
R7218 XFRONT.XFE_E.SB.n24 XFRONT.XFE_E.SB.t4 0.228
R7219 XFRONT.XFE_E.SB.n4 XFRONT.XFE_E.SB.n1 0.1205
R7220 XFRONT.XFE_E.SB.n9 XFRONT.XFE_E.SB.n8 0.1205
R7221 XFRONT.XFE_E.SB.n8 XFRONT.XFE_E.SB.n7 0.1205
R7222 XFRONT.XFE_E.SB.n15 XFRONT.XFE_E.SB.n14 0.1205
R7223 XFRONT.XFE_E.SB.n15 XFRONT.XFE_E.SB.n12 0.1205
R7224 XFRONT.XFE_E.SB.n18 XFRONT.XFE_E.SB.n2 0.1205
R7225 XFRONT.XFE_E.SB.n19 XFRONT.XFE_E.SB.n1 0.0485
R7226 XFRONT.XFE_E.SB.n9 XFRONT.XFE_E.SB.n0 0.0485
R7227 XFRONT.XFE_E.SB.n12 XFRONT.XFE_E.SB.n0 0.0485
R7228 XFRONT.XFE_E.SB.n19 XFRONT.XFE_E.SB.n18 0.0485
R7229 XFRONT.XFE_E.VREGN.n14 XFRONT.XFE_E.VREGN.n6 11.1284
R7230 XFRONT.XFE_E.VREGN.n14 XFRONT.XFE_E.VREGN.n13 8.37084
R7231 XFRONT.XFE_E.VREGN.n1 XFRONT.XFE_E.VREGN.t7 5.73764
R7232 XFRONT.XFE_E.VREGN.n5 XFRONT.XFE_E.VREGN.t0 5.73764
R7233 XFRONT.XFE_E.VREGN.n9 XFRONT.XFE_E.VREGN.n7 5.51014
R7234 XFRONT.XFE_E.VREGN.n9 XFRONT.XFE_E.VREGN.n8 5.32067
R7235 XFRONT.XFE_E.VREGN.n11 XFRONT.XFE_E.VREGN.n10 5.32067
R7236 XFRONT.XFE_E.VREGN.n13 XFRONT.XFE_E.VREGN.n12 5.32067
R7237 XFRONT.XFE_E.VREGN.n1 XFRONT.XFE_E.VREGN.n0 5.32067
R7238 XFRONT.XFE_E.VREGN.n3 XFRONT.XFE_E.VREGN.n2 5.32067
R7239 XFRONT.XFE_E.VREGN.n5 XFRONT.XFE_E.VREGN.n4 5.32067
R7240 XFRONT.XFE_E.VREGN XFRONT.XFE_E.VREGN.n14 4.53963
R7241 XFRONT.XFE_E.VREGN.n7 XFRONT.XFE_E.VREGN.t14 0.228
R7242 XFRONT.XFE_E.VREGN.n7 XFRONT.XFE_E.VREGN.t15 0.228
R7243 XFRONT.XFE_E.VREGN.n8 XFRONT.XFE_E.VREGN.t12 0.228
R7244 XFRONT.XFE_E.VREGN.n8 XFRONT.XFE_E.VREGN.t13 0.228
R7245 XFRONT.XFE_E.VREGN.n10 XFRONT.XFE_E.VREGN.t10 0.228
R7246 XFRONT.XFE_E.VREGN.n10 XFRONT.XFE_E.VREGN.t11 0.228
R7247 XFRONT.XFE_E.VREGN.n12 XFRONT.XFE_E.VREGN.t8 0.228
R7248 XFRONT.XFE_E.VREGN.n12 XFRONT.XFE_E.VREGN.t9 0.228
R7249 XFRONT.XFE_E.VREGN.n0 XFRONT.XFE_E.VREGN.t5 0.228
R7250 XFRONT.XFE_E.VREGN.n0 XFRONT.XFE_E.VREGN.t6 0.228
R7251 XFRONT.XFE_E.VREGN.n2 XFRONT.XFE_E.VREGN.t3 0.228
R7252 XFRONT.XFE_E.VREGN.n2 XFRONT.XFE_E.VREGN.t4 0.228
R7253 XFRONT.XFE_E.VREGN.n4 XFRONT.XFE_E.VREGN.t1 0.228
R7254 XFRONT.XFE_E.VREGN.n4 XFRONT.XFE_E.VREGN.t2 0.228
R7255 XFRONT.XFE_E.VREGN.n3 XFRONT.XFE_E.VREGN.n1 0.189974
R7256 XFRONT.XFE_E.VREGN.n13 XFRONT.XFE_E.VREGN.n11 0.189974
R7257 XFRONT.XFE_E.VREGN.n11 XFRONT.XFE_E.VREGN.n9 0.189974
R7258 XFRONT.XFE_E.VREGN.n6 XFRONT.XFE_E.VREGN.n5 0.0952368
R7259 XFRONT.XFE_E.VREGN.n6 XFRONT.XFE_E.VREGN.n3 0.0952368
R7260 XCAP.O_RST_TAIL.n10 XCAP.O_RST_TAIL.n2 15.9369
R7261 XCAP.O_RST_TAIL.n10 XCAP.O_RST_TAIL.n9 10.957
R7262 XCAP.O_RST_TAIL.n4 XCAP.O_RST_TAIL.t7 5.7796
R7263 XCAP.O_RST_TAIL.n9 XCAP.O_RST_TAIL.t0 5.68486
R7264 XCAP.O_RST_TAIL.n2 XCAP.O_RST_TAIL.n0 5.57485
R7265 XCAP.O_RST_TAIL.n2 XCAP.O_RST_TAIL.n1 5.38537
R7266 XCAP.O_RST_TAIL.n4 XCAP.O_RST_TAIL.n3 5.38537
R7267 XCAP.O_RST_TAIL.n6 XCAP.O_RST_TAIL.n5 5.38537
R7268 XCAP.O_RST_TAIL.n8 XCAP.O_RST_TAIL.n7 5.38537
R7269 XCAP.O_RST_TAIL.n1 XCAP.O_RST_TAIL.t9 0.20525
R7270 XCAP.O_RST_TAIL.n1 XCAP.O_RST_TAIL.t8 0.20525
R7271 XCAP.O_RST_TAIL.n0 XCAP.O_RST_TAIL.t11 0.20525
R7272 XCAP.O_RST_TAIL.n0 XCAP.O_RST_TAIL.t10 0.20525
R7273 XCAP.O_RST_TAIL.n3 XCAP.O_RST_TAIL.t5 0.20525
R7274 XCAP.O_RST_TAIL.n3 XCAP.O_RST_TAIL.t6 0.20525
R7275 XCAP.O_RST_TAIL.n5 XCAP.O_RST_TAIL.t3 0.20525
R7276 XCAP.O_RST_TAIL.n5 XCAP.O_RST_TAIL.t4 0.20525
R7277 XCAP.O_RST_TAIL.n7 XCAP.O_RST_TAIL.t1 0.20525
R7278 XCAP.O_RST_TAIL.n7 XCAP.O_RST_TAIL.t2 0.20525
R7279 XCAP.O_RST_TAIL.n8 XCAP.O_RST_TAIL.n6 0.189974
R7280 XCAP.O_RST_TAIL.n6 XCAP.O_RST_TAIL.n4 0.189974
R7281 XCAP.O_RST_TAIL.n9 XCAP.O_RST_TAIL.n8 0.0952368
R7282 XCAP.O_RST_TAIL XCAP.O_RST_TAIL.n10 0.0396304
R7283 XCAP.E_RST_TAIL.n10 XCAP.E_RST_TAIL.n9 11.9456
R7284 XCAP.E_RST_TAIL.n10 XCAP.E_RST_TAIL.n6 11.6614
R7285 XCAP.E_RST_TAIL.n1 XCAP.E_RST_TAIL.t7 5.7796
R7286 XCAP.E_RST_TAIL.n6 XCAP.E_RST_TAIL.t0 5.68486
R7287 XCAP.E_RST_TAIL.n9 XCAP.E_RST_TAIL.n7 5.57485
R7288 XCAP.E_RST_TAIL.n9 XCAP.E_RST_TAIL.n8 5.38537
R7289 XCAP.E_RST_TAIL.n1 XCAP.E_RST_TAIL.n0 5.38537
R7290 XCAP.E_RST_TAIL.n3 XCAP.E_RST_TAIL.n2 5.38537
R7291 XCAP.E_RST_TAIL.n5 XCAP.E_RST_TAIL.n4 5.38537
R7292 XCAP.E_RST_TAIL.n8 XCAP.E_RST_TAIL.t9 0.20525
R7293 XCAP.E_RST_TAIL.n8 XCAP.E_RST_TAIL.t8 0.20525
R7294 XCAP.E_RST_TAIL.n7 XCAP.E_RST_TAIL.t11 0.20525
R7295 XCAP.E_RST_TAIL.n7 XCAP.E_RST_TAIL.t10 0.20525
R7296 XCAP.E_RST_TAIL.n0 XCAP.E_RST_TAIL.t5 0.20525
R7297 XCAP.E_RST_TAIL.n0 XCAP.E_RST_TAIL.t6 0.20525
R7298 XCAP.E_RST_TAIL.n2 XCAP.E_RST_TAIL.t3 0.20525
R7299 XCAP.E_RST_TAIL.n2 XCAP.E_RST_TAIL.t4 0.20525
R7300 XCAP.E_RST_TAIL.n4 XCAP.E_RST_TAIL.t1 0.20525
R7301 XCAP.E_RST_TAIL.n4 XCAP.E_RST_TAIL.t2 0.20525
R7302 XCAP.E_RST_TAIL.n5 XCAP.E_RST_TAIL.n3 0.189974
R7303 XCAP.E_RST_TAIL.n3 XCAP.E_RST_TAIL.n1 0.189974
R7304 XCAP.E_RST_TAIL.n6 XCAP.E_RST_TAIL.n5 0.0952368
R7305 XCAP.E_RST_TAIL XCAP.E_RST_TAIL.n10 0.0396304
R7306 XCAP.O_SET_TAIL.n9 XCAP.O_SET_TAIL.n5 11.3875
R7307 XCAP.O_SET_TAIL.n9 XCAP.O_SET_TAIL.n8 9.68219
R7308 XCAP.O_SET_TAIL.n1 XCAP.O_SET_TAIL.t11 5.7796
R7309 XCAP.O_SET_TAIL.n5 XCAP.O_SET_TAIL.t4 5.7796
R7310 XCAP.O_SET_TAIL.n8 XCAP.O_SET_TAIL.n6 5.57485
R7311 XCAP.O_SET_TAIL.n1 XCAP.O_SET_TAIL.n0 5.38537
R7312 XCAP.O_SET_TAIL.n3 XCAP.O_SET_TAIL.n2 5.38537
R7313 XCAP.O_SET_TAIL.n8 XCAP.O_SET_TAIL.n7 5.38537
R7314 XCAP.O_SET_TAIL.n5 XCAP.O_SET_TAIL.n4 5.38537
R7315 XCAP.O_SET_TAIL.n0 XCAP.O_SET_TAIL.t9 0.20525
R7316 XCAP.O_SET_TAIL.n0 XCAP.O_SET_TAIL.t10 0.20525
R7317 XCAP.O_SET_TAIL.n2 XCAP.O_SET_TAIL.t7 0.20525
R7318 XCAP.O_SET_TAIL.n2 XCAP.O_SET_TAIL.t8 0.20525
R7319 XCAP.O_SET_TAIL.n7 XCAP.O_SET_TAIL.t1 0.20525
R7320 XCAP.O_SET_TAIL.n7 XCAP.O_SET_TAIL.t0 0.20525
R7321 XCAP.O_SET_TAIL.n6 XCAP.O_SET_TAIL.t3 0.20525
R7322 XCAP.O_SET_TAIL.n6 XCAP.O_SET_TAIL.t2 0.20525
R7323 XCAP.O_SET_TAIL.n4 XCAP.O_SET_TAIL.t5 0.20525
R7324 XCAP.O_SET_TAIL.n4 XCAP.O_SET_TAIL.t6 0.20525
R7325 XCAP.O_SET_TAIL.n5 XCAP.O_SET_TAIL.n3 0.189974
R7326 XCAP.O_SET_TAIL.n3 XCAP.O_SET_TAIL.n1 0.189974
R7327 XCAP.O_SET_TAIL XCAP.O_SET_TAIL.n9 0.0396304
R7328 XCAP.E_SET_TAIL.n9 XCAP.E_SET_TAIL.n2 12.1083
R7329 XCAP.E_SET_TAIL.n9 XCAP.E_SET_TAIL.n8 10.2135
R7330 XCAP.E_SET_TAIL.n4 XCAP.E_SET_TAIL.t9 5.7796
R7331 XCAP.E_SET_TAIL.n8 XCAP.E_SET_TAIL.t2 5.7796
R7332 XCAP.E_SET_TAIL.n2 XCAP.E_SET_TAIL.n0 5.57485
R7333 XCAP.E_SET_TAIL.n4 XCAP.E_SET_TAIL.n3 5.38537
R7334 XCAP.E_SET_TAIL.n6 XCAP.E_SET_TAIL.n5 5.38537
R7335 XCAP.E_SET_TAIL.n2 XCAP.E_SET_TAIL.n1 5.38537
R7336 XCAP.E_SET_TAIL.n8 XCAP.E_SET_TAIL.n7 5.38537
R7337 XCAP.E_SET_TAIL.n3 XCAP.E_SET_TAIL.t7 0.20525
R7338 XCAP.E_SET_TAIL.n3 XCAP.E_SET_TAIL.t8 0.20525
R7339 XCAP.E_SET_TAIL.n5 XCAP.E_SET_TAIL.t5 0.20525
R7340 XCAP.E_SET_TAIL.n5 XCAP.E_SET_TAIL.t6 0.20525
R7341 XCAP.E_SET_TAIL.n1 XCAP.E_SET_TAIL.t11 0.20525
R7342 XCAP.E_SET_TAIL.n1 XCAP.E_SET_TAIL.t10 0.20525
R7343 XCAP.E_SET_TAIL.n0 XCAP.E_SET_TAIL.t1 0.20525
R7344 XCAP.E_SET_TAIL.n0 XCAP.E_SET_TAIL.t0 0.20525
R7345 XCAP.E_SET_TAIL.n7 XCAP.E_SET_TAIL.t3 0.20525
R7346 XCAP.E_SET_TAIL.n7 XCAP.E_SET_TAIL.t4 0.20525
R7347 XCAP.E_SET_TAIL.n8 XCAP.E_SET_TAIL.n6 0.189974
R7348 XCAP.E_SET_TAIL.n6 XCAP.E_SET_TAIL.n4 0.189974
R7349 XCAP.E_SET_TAIL XCAP.E_SET_TAIL.n9 0.0396304
R7350 XCAP.O_PSET_TAIL.n10 XCAP.O_PSET_TAIL.n2 15.7351
R7351 XCAP.O_PSET_TAIL.n10 XCAP.O_PSET_TAIL.n9 12.6005
R7352 XCAP.O_PSET_TAIL.n4 XCAP.O_PSET_TAIL.t11 5.73764
R7353 XCAP.O_PSET_TAIL.n9 XCAP.O_PSET_TAIL.t4 5.54817
R7354 XCAP.O_PSET_TAIL.n2 XCAP.O_PSET_TAIL.n0 5.51014
R7355 XCAP.O_PSET_TAIL.n4 XCAP.O_PSET_TAIL.n3 5.32067
R7356 XCAP.O_PSET_TAIL.n6 XCAP.O_PSET_TAIL.n5 5.32067
R7357 XCAP.O_PSET_TAIL.n8 XCAP.O_PSET_TAIL.n7 5.32067
R7358 XCAP.O_PSET_TAIL.n2 XCAP.O_PSET_TAIL.n1 5.32067
R7359 XCAP.O_PSET_TAIL.n3 XCAP.O_PSET_TAIL.t9 0.228
R7360 XCAP.O_PSET_TAIL.n3 XCAP.O_PSET_TAIL.t10 0.228
R7361 XCAP.O_PSET_TAIL.n5 XCAP.O_PSET_TAIL.t7 0.228
R7362 XCAP.O_PSET_TAIL.n5 XCAP.O_PSET_TAIL.t8 0.228
R7363 XCAP.O_PSET_TAIL.n7 XCAP.O_PSET_TAIL.t5 0.228
R7364 XCAP.O_PSET_TAIL.n7 XCAP.O_PSET_TAIL.t6 0.228
R7365 XCAP.O_PSET_TAIL.n1 XCAP.O_PSET_TAIL.t1 0.228
R7366 XCAP.O_PSET_TAIL.n1 XCAP.O_PSET_TAIL.t0 0.228
R7367 XCAP.O_PSET_TAIL.n0 XCAP.O_PSET_TAIL.t3 0.228
R7368 XCAP.O_PSET_TAIL.n0 XCAP.O_PSET_TAIL.t2 0.228
R7369 XCAP.O_PSET_TAIL.n9 XCAP.O_PSET_TAIL.n8 0.189974
R7370 XCAP.O_PSET_TAIL.n8 XCAP.O_PSET_TAIL.n6 0.189974
R7371 XCAP.O_PSET_TAIL.n6 XCAP.O_PSET_TAIL.n4 0.189974
R7372 XCAP.O_PSET_TAIL XCAP.O_PSET_TAIL.n10 0.0396304
R7373 XCAP.E_PSET_TAIL.n10 XCAP.E_PSET_TAIL.n6 15.4962
R7374 XCAP.E_PSET_TAIL.n10 XCAP.E_PSET_TAIL.n9 12.1804
R7375 XCAP.E_PSET_TAIL.n1 XCAP.E_PSET_TAIL.t7 5.73764
R7376 XCAP.E_PSET_TAIL.n6 XCAP.E_PSET_TAIL.t0 5.54817
R7377 XCAP.E_PSET_TAIL.n9 XCAP.E_PSET_TAIL.n7 5.51014
R7378 XCAP.E_PSET_TAIL.n1 XCAP.E_PSET_TAIL.n0 5.32067
R7379 XCAP.E_PSET_TAIL.n3 XCAP.E_PSET_TAIL.n2 5.32067
R7380 XCAP.E_PSET_TAIL.n5 XCAP.E_PSET_TAIL.n4 5.32067
R7381 XCAP.E_PSET_TAIL.n9 XCAP.E_PSET_TAIL.n8 5.32067
R7382 XCAP.E_PSET_TAIL.n0 XCAP.E_PSET_TAIL.t5 0.228
R7383 XCAP.E_PSET_TAIL.n0 XCAP.E_PSET_TAIL.t6 0.228
R7384 XCAP.E_PSET_TAIL.n2 XCAP.E_PSET_TAIL.t3 0.228
R7385 XCAP.E_PSET_TAIL.n2 XCAP.E_PSET_TAIL.t4 0.228
R7386 XCAP.E_PSET_TAIL.n4 XCAP.E_PSET_TAIL.t1 0.228
R7387 XCAP.E_PSET_TAIL.n4 XCAP.E_PSET_TAIL.t2 0.228
R7388 XCAP.E_PSET_TAIL.n7 XCAP.E_PSET_TAIL.t10 0.228
R7389 XCAP.E_PSET_TAIL.n7 XCAP.E_PSET_TAIL.t9 0.228
R7390 XCAP.E_PSET_TAIL.n8 XCAP.E_PSET_TAIL.t8 0.228
R7391 XCAP.E_PSET_TAIL.n8 XCAP.E_PSET_TAIL.t11 0.228
R7392 XCAP.E_PSET_TAIL.n6 XCAP.E_PSET_TAIL.n5 0.189974
R7393 XCAP.E_PSET_TAIL.n5 XCAP.E_PSET_TAIL.n3 0.189974
R7394 XCAP.E_PSET_TAIL.n3 XCAP.E_PSET_TAIL.n1 0.189974
R7395 XCAP.E_PSET_TAIL XCAP.E_PSET_TAIL.n10 0.0396304
R7396 XCAP.O_QI.n0 XCAP.O_QI.t19 113.632
R7397 XCAP.O_QI.n16 XCAP.O_QI.t12 113.618
R7398 XCAP.O_QI.n16 XCAP.O_QI.t13 113.618
R7399 XCAP.O_QI.n15 XCAP.O_QI.t16 113.618
R7400 XCAP.O_QI.n15 XCAP.O_QI.t17 113.618
R7401 XCAP.O_QI.n0 XCAP.O_QI.t18 113.603
R7402 XCAP.O_QI.n1 XCAP.O_QI.t15 61.4885
R7403 XCAP.O_QI.n1 XCAP.O_QI.t14 61.4598
R7404 XCAP.O_QI.n2 XCAP.O_QI.n0 21.3118
R7405 XCAP.O_QI.n17 XCAP.O_QI.n15 19.4852
R7406 XCAP.O_QI.n17 XCAP.O_QI.n16 17.5287
R7407 XCAP.O_QI.n2 XCAP.O_QI.n1 16.2249
R7408 XCAP.O_QI.n14 XCAP.O_QI.n2 10.9375
R7409 XCAP.O_QI.n13 XCAP.O_QI.n12 9.70485
R7410 XCAP.O_QI.n7 XCAP.O_QI.n5 7.43528
R7411 XCAP.O_QI.n11 XCAP.O_QI.t8 5.7796
R7412 XCAP.O_QI.n8 XCAP.O_QI.t2 5.7796
R7413 XCAP.O_QI.n6 XCAP.O_QI.t0 5.73764
R7414 XCAP.O_QI.n4 XCAP.O_QI.t3 5.73764
R7415 XCAP.O_QI.n12 XCAP.O_QI.t11 5.68486
R7416 XCAP.O_QI.n5 XCAP.O_QI.t6 5.6429
R7417 XCAP.O_QI.n8 XCAP.O_QI.t7 5.59012
R7418 XCAP.O_QI.n6 XCAP.O_QI.t1 5.54817
R7419 XCAP.O_QI.n11 XCAP.O_QI.n10 5.38537
R7420 XCAP.O_QI.n4 XCAP.O_QI.n3 5.32067
R7421 XCAP.O_QI.n9 XCAP.O_QI.n7 4.8918
R7422 XCAP.O_QI.n7 XCAP.O_QI.n6 4.5005
R7423 XCAP.O_QI.n9 XCAP.O_QI.n8 4.5005
R7424 XCAP.O_QI.n14 XCAP.O_QI.n13 4.5005
R7425 XCAP.O_QI.n18 XCAP.O_QI.n17 4.5005
R7426 XCAP.O_QI.n18 XCAP.O_QI.n14 2.1918
R7427 XCAP.O_QI.n3 XCAP.O_QI.t5 0.228
R7428 XCAP.O_QI.n3 XCAP.O_QI.t4 0.228
R7429 XCAP.O_QI.n10 XCAP.O_QI.t10 0.20525
R7430 XCAP.O_QI.n10 XCAP.O_QI.t9 0.20525
R7431 XCAP.O_QI.n12 XCAP.O_QI.n11 0.0952368
R7432 XCAP.O_QI.n5 XCAP.O_QI.n4 0.0952368
R7433 XCAP.O_QI.n13 XCAP.O_QI.n9 0.0787609
R7434 XCAP.O_QI XCAP.O_QI.n18 0.0396304
R7435 XCAP.ODD_DB_BUF.n18 XCAP.ODD_DB_BUF.t12 113.632
R7436 XCAP.ODD_DB_BUF.n12 XCAP.ODD_DB_BUF.t16 113.632
R7437 XCAP.ODD_DB_BUF.n21 XCAP.ODD_DB_BUF.t15 109.174
R7438 XCAP.ODD_DB_BUF.n20 XCAP.ODD_DB_BUF.t14 109.174
R7439 XCAP.ODD_DB_BUF.n19 XCAP.ODD_DB_BUF.t13 109.174
R7440 XCAP.ODD_DB_BUF.n13 XCAP.ODD_DB_BUF.t17 109.174
R7441 XCAP.ODD_DB_BUF.n14 XCAP.ODD_DB_BUF.t18 109.174
R7442 XCAP.ODD_DB_BUF.n15 XCAP.ODD_DB_BUF.t19 109.174
R7443 XCAP.ODD_DB_BUF.n23 XCAP.ODD_DB_BUF.n22 21.6707
R7444 XCAP.ODD_DB_BUF.n22 XCAP.ODD_DB_BUF.n21 18.4942
R7445 XCAP.ODD_DB_BUF.n20 XCAP.ODD_DB_BUF.n17 18.4942
R7446 XCAP.ODD_DB_BUF.n14 XCAP.ODD_DB_BUF.n11 18.4942
R7447 XCAP.ODD_DB_BUF.n16 XCAP.ODD_DB_BUF.n15 18.4942
R7448 XCAP.ODD_DB_BUF.n21 XCAP.ODD_DB_BUF.n20 11.6805
R7449 XCAP.ODD_DB_BUF.n20 XCAP.ODD_DB_BUF.n19 11.6805
R7450 XCAP.ODD_DB_BUF.n14 XCAP.ODD_DB_BUF.n13 11.6805
R7451 XCAP.ODD_DB_BUF.n15 XCAP.ODD_DB_BUF.n14 11.6805
R7452 XCAP.ODD_DB_BUF.n10 XCAP.ODD_DB_BUF.n2 10.3701
R7453 XCAP.ODD_DB_BUF.n23 XCAP.ODD_DB_BUF.n16 9.77502
R7454 XCAP.ODD_DB_BUF.n24 XCAP.ODD_DB_BUF.n10 7.94398
R7455 XCAP.ODD_DB_BUF.n18 XCAP.ODD_DB_BUF.n17 7.17687
R7456 XCAP.ODD_DB_BUF.n12 XCAP.ODD_DB_BUF.n11 7.17687
R7457 XCAP.ODD_DB_BUF.n1 XCAP.ODD_DB_BUF.t11 5.7796
R7458 XCAP.ODD_DB_BUF.n4 XCAP.ODD_DB_BUF.t7 5.73764
R7459 XCAP.ODD_DB_BUF.n8 XCAP.ODD_DB_BUF.t0 5.73764
R7460 XCAP.ODD_DB_BUF.n2 XCAP.ODD_DB_BUF.t8 5.68486
R7461 XCAP.ODD_DB_BUF.n1 XCAP.ODD_DB_BUF.n0 5.38537
R7462 XCAP.ODD_DB_BUF.n4 XCAP.ODD_DB_BUF.n3 5.32067
R7463 XCAP.ODD_DB_BUF.n6 XCAP.ODD_DB_BUF.n5 5.32067
R7464 XCAP.ODD_DB_BUF.n8 XCAP.ODD_DB_BUF.n7 5.32067
R7465 XCAP.ODD_DB_BUF.n10 XCAP.ODD_DB_BUF.n9 4.5005
R7466 XCAP.ODD_DB_BUF.n24 XCAP.ODD_DB_BUF.n23 4.5005
R7467 XCAP.ODD_DB_BUF.n19 XCAP.ODD_DB_BUF.n18 4.42851
R7468 XCAP.ODD_DB_BUF.n13 XCAP.ODD_DB_BUF.n12 4.42851
R7469 XCAP.ODD_DB_BUF.n3 XCAP.ODD_DB_BUF.t5 0.228
R7470 XCAP.ODD_DB_BUF.n3 XCAP.ODD_DB_BUF.t6 0.228
R7471 XCAP.ODD_DB_BUF.n5 XCAP.ODD_DB_BUF.t3 0.228
R7472 XCAP.ODD_DB_BUF.n5 XCAP.ODD_DB_BUF.t4 0.228
R7473 XCAP.ODD_DB_BUF.n7 XCAP.ODD_DB_BUF.t1 0.228
R7474 XCAP.ODD_DB_BUF.n7 XCAP.ODD_DB_BUF.t2 0.228
R7475 XCAP.ODD_DB_BUF.n0 XCAP.ODD_DB_BUF.t9 0.20525
R7476 XCAP.ODD_DB_BUF.n0 XCAP.ODD_DB_BUF.t10 0.20525
R7477 XCAP.ODD_DB_BUF.n6 XCAP.ODD_DB_BUF.n4 0.189974
R7478 XCAP.ODD_DB_BUF.n22 XCAP.ODD_DB_BUF.n17 0.1205
R7479 XCAP.ODD_DB_BUF.n16 XCAP.ODD_DB_BUF.n11 0.1205
R7480 XCAP.ODD_DB_BUF.n9 XCAP.ODD_DB_BUF.n8 0.0952368
R7481 XCAP.ODD_DB_BUF.n9 XCAP.ODD_DB_BUF.n6 0.0952368
R7482 XCAP.ODD_DB_BUF.n2 XCAP.ODD_DB_BUF.n1 0.0952368
R7483 XCAP.ODD_DB_BUF XCAP.ODD_DB_BUF.n24 0.0396304
R7484 XCAP.EVEN_DB_BUF.n7 XCAP.EVEN_DB_BUF.t12 113.632
R7485 XCAP.EVEN_DB_BUF.n1 XCAP.EVEN_DB_BUF.t16 113.632
R7486 XCAP.EVEN_DB_BUF.n10 XCAP.EVEN_DB_BUF.t15 109.174
R7487 XCAP.EVEN_DB_BUF.n9 XCAP.EVEN_DB_BUF.t14 109.174
R7488 XCAP.EVEN_DB_BUF.n8 XCAP.EVEN_DB_BUF.t13 109.174
R7489 XCAP.EVEN_DB_BUF.n2 XCAP.EVEN_DB_BUF.t17 109.174
R7490 XCAP.EVEN_DB_BUF.n3 XCAP.EVEN_DB_BUF.t18 109.174
R7491 XCAP.EVEN_DB_BUF.n4 XCAP.EVEN_DB_BUF.t19 109.174
R7492 XCAP.EVEN_DB_BUF.n12 XCAP.EVEN_DB_BUF.n11 21.1228
R7493 XCAP.EVEN_DB_BUF.n11 XCAP.EVEN_DB_BUF.n10 18.4942
R7494 XCAP.EVEN_DB_BUF.n9 XCAP.EVEN_DB_BUF.n6 18.4942
R7495 XCAP.EVEN_DB_BUF.n3 XCAP.EVEN_DB_BUF.n0 18.4942
R7496 XCAP.EVEN_DB_BUF.n5 XCAP.EVEN_DB_BUF.n4 18.4942
R7497 XCAP.EVEN_DB_BUF.n10 XCAP.EVEN_DB_BUF.n9 11.6805
R7498 XCAP.EVEN_DB_BUF.n9 XCAP.EVEN_DB_BUF.n8 11.6805
R7499 XCAP.EVEN_DB_BUF.n3 XCAP.EVEN_DB_BUF.n2 11.6805
R7500 XCAP.EVEN_DB_BUF.n4 XCAP.EVEN_DB_BUF.n3 11.6805
R7501 XCAP.EVEN_DB_BUF.n23 XCAP.EVEN_DB_BUF.n15 10.3701
R7502 XCAP.EVEN_DB_BUF.n12 XCAP.EVEN_DB_BUF.n5 10.3228
R7503 XCAP.EVEN_DB_BUF.n7 XCAP.EVEN_DB_BUF.n6 7.17687
R7504 XCAP.EVEN_DB_BUF.n1 XCAP.EVEN_DB_BUF.n0 7.17687
R7505 XCAP.EVEN_DB_BUF.n24 XCAP.EVEN_DB_BUF.n12 6.53528
R7506 XCAP.EVEN_DB_BUF.n14 XCAP.EVEN_DB_BUF.t11 5.7796
R7507 XCAP.EVEN_DB_BUF.n17 XCAP.EVEN_DB_BUF.t7 5.73764
R7508 XCAP.EVEN_DB_BUF.n21 XCAP.EVEN_DB_BUF.t0 5.73764
R7509 XCAP.EVEN_DB_BUF.n15 XCAP.EVEN_DB_BUF.t8 5.68486
R7510 XCAP.EVEN_DB_BUF.n14 XCAP.EVEN_DB_BUF.n13 5.38537
R7511 XCAP.EVEN_DB_BUF.n17 XCAP.EVEN_DB_BUF.n16 5.32067
R7512 XCAP.EVEN_DB_BUF.n19 XCAP.EVEN_DB_BUF.n18 5.32067
R7513 XCAP.EVEN_DB_BUF.n21 XCAP.EVEN_DB_BUF.n20 5.32067
R7514 XCAP.EVEN_DB_BUF.n24 XCAP.EVEN_DB_BUF.n23 4.73528
R7515 XCAP.EVEN_DB_BUF.n23 XCAP.EVEN_DB_BUF.n22 4.5005
R7516 XCAP.EVEN_DB_BUF.n8 XCAP.EVEN_DB_BUF.n7 4.42851
R7517 XCAP.EVEN_DB_BUF.n2 XCAP.EVEN_DB_BUF.n1 4.42851
R7518 XCAP.EVEN_DB_BUF.n16 XCAP.EVEN_DB_BUF.t5 0.228
R7519 XCAP.EVEN_DB_BUF.n16 XCAP.EVEN_DB_BUF.t6 0.228
R7520 XCAP.EVEN_DB_BUF.n18 XCAP.EVEN_DB_BUF.t3 0.228
R7521 XCAP.EVEN_DB_BUF.n18 XCAP.EVEN_DB_BUF.t4 0.228
R7522 XCAP.EVEN_DB_BUF.n20 XCAP.EVEN_DB_BUF.t1 0.228
R7523 XCAP.EVEN_DB_BUF.n20 XCAP.EVEN_DB_BUF.t2 0.228
R7524 XCAP.EVEN_DB_BUF.n13 XCAP.EVEN_DB_BUF.t9 0.20525
R7525 XCAP.EVEN_DB_BUF.n13 XCAP.EVEN_DB_BUF.t10 0.20525
R7526 XCAP.EVEN_DB_BUF.n19 XCAP.EVEN_DB_BUF.n17 0.189974
R7527 XCAP.EVEN_DB_BUF.n11 XCAP.EVEN_DB_BUF.n6 0.1205
R7528 XCAP.EVEN_DB_BUF.n5 XCAP.EVEN_DB_BUF.n0 0.1205
R7529 XCAP.EVEN_DB_BUF.n22 XCAP.EVEN_DB_BUF.n21 0.0952368
R7530 XCAP.EVEN_DB_BUF.n22 XCAP.EVEN_DB_BUF.n19 0.0952368
R7531 XCAP.EVEN_DB_BUF.n15 XCAP.EVEN_DB_BUF.n14 0.0952368
R7532 XCAP.EVEN_DB_BUF XCAP.EVEN_DB_BUF.n24 0.0396304
R7533 XCAP.E_QI.n15 XCAP.E_QI.t19 113.632
R7534 XCAP.E_QI.n1 XCAP.E_QI.t12 113.618
R7535 XCAP.E_QI.n1 XCAP.E_QI.t13 113.618
R7536 XCAP.E_QI.n0 XCAP.E_QI.t16 113.618
R7537 XCAP.E_QI.n0 XCAP.E_QI.t17 113.618
R7538 XCAP.E_QI.n15 XCAP.E_QI.t18 113.603
R7539 XCAP.E_QI.n16 XCAP.E_QI.t15 61.4885
R7540 XCAP.E_QI.n16 XCAP.E_QI.t14 61.4598
R7541 XCAP.E_QI.n17 XCAP.E_QI.n15 21.3118
R7542 XCAP.E_QI.n2 XCAP.E_QI.n0 20.0331
R7543 XCAP.E_QI.n2 XCAP.E_QI.n1 16.9809
R7544 XCAP.E_QI.n17 XCAP.E_QI.n16 16.2249
R7545 XCAP.E_QI.n13 XCAP.E_QI.n12 9.15702
R7546 XCAP.E_QI.n7 XCAP.E_QI.n5 7.43528
R7547 XCAP.E_QI.n14 XCAP.E_QI.n2 7.00485
R7548 XCAP.E_QI.n18 XCAP.E_QI.n17 6.32007
R7549 XCAP.E_QI.n11 XCAP.E_QI.t10 5.7796
R7550 XCAP.E_QI.n8 XCAP.E_QI.t1 5.7796
R7551 XCAP.E_QI.n4 XCAP.E_QI.t6 5.73764
R7552 XCAP.E_QI.n6 XCAP.E_QI.t11 5.73764
R7553 XCAP.E_QI.n12 XCAP.E_QI.t7 5.68486
R7554 XCAP.E_QI.n5 XCAP.E_QI.t3 5.6429
R7555 XCAP.E_QI.n8 XCAP.E_QI.t0 5.59012
R7556 XCAP.E_QI.n6 XCAP.E_QI.t2 5.54817
R7557 XCAP.E_QI.n11 XCAP.E_QI.n10 5.38537
R7558 XCAP.E_QI.n4 XCAP.E_QI.n3 5.32067
R7559 XCAP.E_QI.n9 XCAP.E_QI.n7 4.8918
R7560 XCAP.E_QI.n7 XCAP.E_QI.n6 4.5005
R7561 XCAP.E_QI.n9 XCAP.E_QI.n8 4.5005
R7562 XCAP.E_QI.n14 XCAP.E_QI.n13 4.5005
R7563 XCAP.E_QI.n18 XCAP.E_QI.n14 4.22659
R7564 XCAP.E_QI.n13 XCAP.E_QI.n9 0.626587
R7565 XCAP.E_QI.n3 XCAP.E_QI.t4 0.228
R7566 XCAP.E_QI.n3 XCAP.E_QI.t5 0.228
R7567 XCAP.E_QI.n10 XCAP.E_QI.t8 0.20525
R7568 XCAP.E_QI.n10 XCAP.E_QI.t9 0.20525
R7569 XCAP.E_QI.n5 XCAP.E_QI.n4 0.0952368
R7570 XCAP.E_QI.n12 XCAP.E_QI.n11 0.0952368
R7571 XCAP.E_QI XCAP.E_QI.n18 0.0396304
R7572 XCAP.O_QBBUF.n0 XCAP.O_QBBUF.t7 113.632
R7573 XCAP.O_QBBUF.n3 XCAP.O_QBBUF.t10 113.632
R7574 XCAP.O_QBBUF.n7 XCAP.O_QBBUF.t6 113.629
R7575 XCAP.O_QBBUF.n5 XCAP.O_QBBUF.t4 109.174
R7576 XCAP.O_QBBUF.n6 XCAP.O_QBBUF.t5 109.174
R7577 XCAP.O_QBBUF.n1 XCAP.O_QBBUF.t8 109.174
R7578 XCAP.O_QBBUF.n2 XCAP.O_QBBUF.t9 109.174
R7579 XCAP.O_QBBUF.n8 XCAP.O_QBBUF.n5 18.6022
R7580 XCAP.O_QBBUF.n9 XCAP.O_QBBUF.n4 17.394
R7581 XCAP.O_QBBUF.n6 XCAP.O_QBBUF.n5 11.6805
R7582 XCAP.O_QBBUF.n2 XCAP.O_QBBUF.n1 11.6805
R7583 XCAP.O_QBBUF.n12 XCAP.O_QBBUF.n10 10.4648
R7584 XCAP.O_QBBUF.n9 XCAP.O_QBBUF.n8 9.21572
R7585 XCAP.O_QBBUF.n13 XCAP.O_QBBUF.n9 7.16137
R7586 XCAP.O_QBBUF.n4 XCAP.O_QBBUF.n0 7.10487
R7587 XCAP.O_QBBUF.n4 XCAP.O_QBBUF.n3 7.10487
R7588 XCAP.O_QBBUF.n8 XCAP.O_QBBUF.n7 7.05405
R7589 XCAP.O_QBBUF.n11 XCAP.O_QBBUF.t3 6.07983
R7590 XCAP.O_QBBUF.n11 XCAP.O_QBBUF.t2 5.89036
R7591 XCAP.O_QBBUF.n10 XCAP.O_QBBUF.t1 5.73764
R7592 XCAP.O_QBBUF.n10 XCAP.O_QBBUF.t0 5.54817
R7593 XCAP.O_QBBUF.n13 XCAP.O_QBBUF.n12 5.43963
R7594 XCAP.O_QBBUF.n12 XCAP.O_QBBUF.n11 4.59524
R7595 XCAP.O_QBBUF.n7 XCAP.O_QBBUF.n6 4.4296
R7596 XCAP.O_QBBUF.n1 XCAP.O_QBBUF.n0 4.42851
R7597 XCAP.O_QBBUF.n3 XCAP.O_QBBUF.n2 4.42851
R7598 XCAP.O_QBBUF XCAP.O_QBBUF.n13 0.0396304
R7599 XCAP.O_QBUF.n0 XCAP.O_QBUF.t7 113.632
R7600 XCAP.O_QBUF.n3 XCAP.O_QBUF.t10 113.632
R7601 XCAP.O_QBUF.n7 XCAP.O_QBUF.t6 113.629
R7602 XCAP.O_QBUF.n5 XCAP.O_QBUF.t4 109.174
R7603 XCAP.O_QBUF.n6 XCAP.O_QBUF.t5 109.174
R7604 XCAP.O_QBUF.n1 XCAP.O_QBUF.t8 109.174
R7605 XCAP.O_QBUF.n2 XCAP.O_QBUF.t9 109.174
R7606 XCAP.O_QBUF.n8 XCAP.O_QBUF.n5 18.6022
R7607 XCAP.O_QBUF.n9 XCAP.O_QBUF.n4 17.1201
R7608 XCAP.O_QBUF.n6 XCAP.O_QBUF.n5 11.6805
R7609 XCAP.O_QBUF.n2 XCAP.O_QBUF.n1 11.6805
R7610 XCAP.O_QBUF.n12 XCAP.O_QBUF.n10 10.4648
R7611 XCAP.O_QBUF.n9 XCAP.O_QBUF.n8 9.48963
R7612 XCAP.O_QBUF.n13 XCAP.O_QBUF.n9 7.16137
R7613 XCAP.O_QBUF.n4 XCAP.O_QBUF.n0 7.10487
R7614 XCAP.O_QBUF.n4 XCAP.O_QBUF.n3 7.10487
R7615 XCAP.O_QBUF.n8 XCAP.O_QBUF.n7 7.05405
R7616 XCAP.O_QBUF.n11 XCAP.O_QBUF.t2 6.07983
R7617 XCAP.O_QBUF.n11 XCAP.O_QBUF.t0 5.89036
R7618 XCAP.O_QBUF.n10 XCAP.O_QBUF.t1 5.73764
R7619 XCAP.O_QBUF.n10 XCAP.O_QBUF.t3 5.54817
R7620 XCAP.O_QBUF.n13 XCAP.O_QBUF.n12 5.16572
R7621 XCAP.O_QBUF.n12 XCAP.O_QBUF.n11 4.59524
R7622 XCAP.O_QBUF.n7 XCAP.O_QBUF.n6 4.4296
R7623 XCAP.O_QBUF.n1 XCAP.O_QBUF.n0 4.42851
R7624 XCAP.O_QBUF.n3 XCAP.O_QBUF.n2 4.42851
R7625 XCAP.O_QBUF XCAP.O_QBUF.n13 0.0396304
R7626 XCAP.E_QBUF.n3 XCAP.E_QBUF.t7 113.632
R7627 XCAP.E_QBUF.n6 XCAP.E_QBUF.t10 113.632
R7628 XCAP.E_QBUF.n10 XCAP.E_QBUF.t6 113.629
R7629 XCAP.E_QBUF.n8 XCAP.E_QBUF.t4 109.174
R7630 XCAP.E_QBUF.n9 XCAP.E_QBUF.t5 109.174
R7631 XCAP.E_QBUF.n4 XCAP.E_QBUF.t8 109.174
R7632 XCAP.E_QBUF.n5 XCAP.E_QBUF.t9 109.174
R7633 XCAP.E_QBUF.n11 XCAP.E_QBUF.n8 18.6022
R7634 XCAP.E_QBUF.n12 XCAP.E_QBUF.n7 17.6092
R7635 XCAP.E_QBUF.n9 XCAP.E_QBUF.n8 11.6805
R7636 XCAP.E_QBUF.n5 XCAP.E_QBUF.n4 11.6805
R7637 XCAP.E_QBUF.n2 XCAP.E_QBUF.n0 10.4648
R7638 XCAP.E_QBUF.n12 XCAP.E_QBUF.n11 9.0005
R7639 XCAP.E_QBUF.n13 XCAP.E_QBUF.n2 7.74833
R7640 XCAP.E_QBUF.n7 XCAP.E_QBUF.n3 7.10487
R7641 XCAP.E_QBUF.n7 XCAP.E_QBUF.n6 7.10487
R7642 XCAP.E_QBUF.n11 XCAP.E_QBUF.n10 7.05405
R7643 XCAP.E_QBUF.n1 XCAP.E_QBUF.t1 6.07983
R7644 XCAP.E_QBUF.n1 XCAP.E_QBUF.t3 5.89036
R7645 XCAP.E_QBUF.n0 XCAP.E_QBUF.t2 5.73764
R7646 XCAP.E_QBUF.n0 XCAP.E_QBUF.t0 5.54817
R7647 XCAP.E_QBUF.n2 XCAP.E_QBUF.n1 4.59524
R7648 XCAP.E_QBUF.n13 XCAP.E_QBUF.n12 4.5592
R7649 XCAP.E_QBUF.n10 XCAP.E_QBUF.n9 4.4296
R7650 XCAP.E_QBUF.n4 XCAP.E_QBUF.n3 4.42851
R7651 XCAP.E_QBUF.n6 XCAP.E_QBUF.n5 4.42851
R7652 XCAP.E_QBUF XCAP.E_QBUF.n13 0.0396304
R7653 XCAP.E_QBBUF.n3 XCAP.E_QBBUF.t7 113.632
R7654 XCAP.E_QBBUF.n6 XCAP.E_QBBUF.t10 113.632
R7655 XCAP.E_QBBUF.n10 XCAP.E_QBBUF.t6 113.629
R7656 XCAP.E_QBBUF.n8 XCAP.E_QBBUF.t4 109.174
R7657 XCAP.E_QBBUF.n9 XCAP.E_QBBUF.t5 109.174
R7658 XCAP.E_QBBUF.n4 XCAP.E_QBBUF.t8 109.174
R7659 XCAP.E_QBBUF.n5 XCAP.E_QBBUF.t9 109.174
R7660 XCAP.E_QBBUF.n11 XCAP.E_QBBUF.n8 18.6022
R7661 XCAP.E_QBBUF.n12 XCAP.E_QBBUF.n7 17.6092
R7662 XCAP.E_QBBUF.n9 XCAP.E_QBBUF.n8 11.6805
R7663 XCAP.E_QBBUF.n5 XCAP.E_QBBUF.n4 11.6805
R7664 XCAP.E_QBBUF.n2 XCAP.E_QBBUF.n0 10.4648
R7665 XCAP.E_QBBUF.n12 XCAP.E_QBBUF.n11 9.0005
R7666 XCAP.E_QBBUF.n13 XCAP.E_QBBUF.n2 8.02224
R7667 XCAP.E_QBBUF.n7 XCAP.E_QBBUF.n3 7.10487
R7668 XCAP.E_QBBUF.n7 XCAP.E_QBBUF.n6 7.10487
R7669 XCAP.E_QBBUF.n11 XCAP.E_QBBUF.n10 7.05405
R7670 XCAP.E_QBBUF.n1 XCAP.E_QBBUF.t3 6.07983
R7671 XCAP.E_QBBUF.n1 XCAP.E_QBBUF.t2 5.89036
R7672 XCAP.E_QBBUF.n0 XCAP.E_QBBUF.t1 5.73764
R7673 XCAP.E_QBBUF.n0 XCAP.E_QBBUF.t0 5.54817
R7674 XCAP.E_QBBUF.n13 XCAP.E_QBBUF.n12 4.83311
R7675 XCAP.E_QBBUF.n2 XCAP.E_QBBUF.n1 4.59524
R7676 XCAP.E_QBBUF.n10 XCAP.E_QBBUF.n9 4.4296
R7677 XCAP.E_QBBUF.n4 XCAP.E_QBBUF.n3 4.42851
R7678 XCAP.E_QBBUF.n6 XCAP.E_QBBUF.n5 4.42851
R7679 XCAP.E_QBBUF XCAP.E_QBBUF.n13 0.0396304
R7680 XCAP.O_QBI.n14 XCAP.O_QBI.t19 113.632
R7681 XCAP.O_QBI.n4 XCAP.O_QBI.t12 113.618
R7682 XCAP.O_QBI.n4 XCAP.O_QBI.t13 113.618
R7683 XCAP.O_QBI.n2 XCAP.O_QBI.t16 113.618
R7684 XCAP.O_QBI.n2 XCAP.O_QBI.t17 113.618
R7685 XCAP.O_QBI.n14 XCAP.O_QBI.t18 113.603
R7686 XCAP.O_QBI.n15 XCAP.O_QBI.t15 61.4885
R7687 XCAP.O_QBI.n15 XCAP.O_QBI.t14 61.4598
R7688 XCAP.O_QBI.n16 XCAP.O_QBI.n14 21.4318
R7689 XCAP.O_QBI.n5 XCAP.O_QBI.n4 17.8026
R7690 XCAP.O_QBI.n16 XCAP.O_QBI.n15 16.3449
R7691 XCAP.O_QBI.n3 XCAP.O_QBI.n2 16.0613
R7692 XCAP.O_QBI.n3 XCAP.O_QBI.n1 14.0679
R7693 XCAP.O_QBI.n12 XCAP.O_QBI.n6 9.19615
R7694 XCAP.O_QBI.n11 XCAP.O_QBI.n9 7.43528
R7695 XCAP.O_QBI.n13 XCAP.O_QBI.n5 7.00485
R7696 XCAP.O_QBI.n8 XCAP.O_QBI.t0 5.7796
R7697 XCAP.O_QBI.n10 XCAP.O_QBI.t11 5.7796
R7698 XCAP.O_QBI.n6 XCAP.O_QBI.t9 5.73764
R7699 XCAP.O_QBI.n1 XCAP.O_QBI.t6 5.73764
R7700 XCAP.O_QBI.n1 XCAP.O_QBI.t5 5.73764
R7701 XCAP.O_QBI.n9 XCAP.O_QBI.t3 5.68486
R7702 XCAP.O_QBI.n10 XCAP.O_QBI.t10 5.59012
R7703 XCAP.O_QBI.n6 XCAP.O_QBI.t8 5.54817
R7704 XCAP.O_QBI.n17 XCAP.O_QBI.n16 5.49833
R7705 XCAP.O_QBI.n8 XCAP.O_QBI.n7 5.38537
R7706 XCAP.O_QBI.n1 XCAP.O_QBI.n0 5.32067
R7707 XCAP.O_QBI.n11 XCAP.O_QBI.n10 4.5005
R7708 XCAP.O_QBI.n13 XCAP.O_QBI.n12 4.5005
R7709 XCAP.O_QBI.n5 XCAP.O_QBI.n3 3.1505
R7710 XCAP.O_QBI.n17 XCAP.O_QBI.n13 2.89615
R7711 XCAP.O_QBI.n0 XCAP.O_QBI.t4 0.228
R7712 XCAP.O_QBI.n0 XCAP.O_QBI.t7 0.228
R7713 XCAP.O_QBI.n7 XCAP.O_QBI.t2 0.20525
R7714 XCAP.O_QBI.n7 XCAP.O_QBI.t1 0.20525
R7715 XCAP.O_QBI.n12 XCAP.O_QBI.n11 0.196152
R7716 XCAP.O_QBI.n9 XCAP.O_QBI.n8 0.0952368
R7717 XCAP.O_QBI XCAP.O_QBI.n17 0.0396304
R7718 XCAP.O_PRST_TAIL.n10 XCAP.O_PRST_TAIL.n2 19.1064
R7719 XCAP.O_PRST_TAIL.n10 XCAP.O_PRST_TAIL.n9 17.603
R7720 XCAP.O_PRST_TAIL.n4 XCAP.O_PRST_TAIL.t11 5.73764
R7721 XCAP.O_PRST_TAIL.n9 XCAP.O_PRST_TAIL.t4 5.54817
R7722 XCAP.O_PRST_TAIL.n2 XCAP.O_PRST_TAIL.n0 5.51014
R7723 XCAP.O_PRST_TAIL.n4 XCAP.O_PRST_TAIL.n3 5.32067
R7724 XCAP.O_PRST_TAIL.n2 XCAP.O_PRST_TAIL.n1 5.32067
R7725 XCAP.O_PRST_TAIL.n6 XCAP.O_PRST_TAIL.n5 5.32067
R7726 XCAP.O_PRST_TAIL.n8 XCAP.O_PRST_TAIL.n7 5.32067
R7727 XCAP.O_PRST_TAIL.n3 XCAP.O_PRST_TAIL.t9 0.228
R7728 XCAP.O_PRST_TAIL.n3 XCAP.O_PRST_TAIL.t10 0.228
R7729 XCAP.O_PRST_TAIL.n0 XCAP.O_PRST_TAIL.t3 0.228
R7730 XCAP.O_PRST_TAIL.n0 XCAP.O_PRST_TAIL.t2 0.228
R7731 XCAP.O_PRST_TAIL.n1 XCAP.O_PRST_TAIL.t1 0.228
R7732 XCAP.O_PRST_TAIL.n1 XCAP.O_PRST_TAIL.t0 0.228
R7733 XCAP.O_PRST_TAIL.n5 XCAP.O_PRST_TAIL.t7 0.228
R7734 XCAP.O_PRST_TAIL.n5 XCAP.O_PRST_TAIL.t8 0.228
R7735 XCAP.O_PRST_TAIL.n7 XCAP.O_PRST_TAIL.t5 0.228
R7736 XCAP.O_PRST_TAIL.n7 XCAP.O_PRST_TAIL.t6 0.228
R7737 XCAP.O_PRST_TAIL.n9 XCAP.O_PRST_TAIL.n8 0.189974
R7738 XCAP.O_PRST_TAIL.n8 XCAP.O_PRST_TAIL.n6 0.189974
R7739 XCAP.O_PRST_TAIL.n6 XCAP.O_PRST_TAIL.n4 0.189974
R7740 XCAP.O_PRST_TAIL XCAP.O_PRST_TAIL.n10 0.0396304
R7741 XCAP.E_PRST_TAIL.n10 XCAP.E_PRST_TAIL.n6 24.2305
R7742 XCAP.E_PRST_TAIL.n10 XCAP.E_PRST_TAIL.n9 17.0881
R7743 XCAP.E_PRST_TAIL.n1 XCAP.E_PRST_TAIL.t2 5.73764
R7744 XCAP.E_PRST_TAIL.n6 XCAP.E_PRST_TAIL.t9 5.54817
R7745 XCAP.E_PRST_TAIL.n9 XCAP.E_PRST_TAIL.n7 5.51014
R7746 XCAP.E_PRST_TAIL.n9 XCAP.E_PRST_TAIL.n8 5.32067
R7747 XCAP.E_PRST_TAIL.n5 XCAP.E_PRST_TAIL.n4 5.32067
R7748 XCAP.E_PRST_TAIL.n3 XCAP.E_PRST_TAIL.n2 5.32067
R7749 XCAP.E_PRST_TAIL.n1 XCAP.E_PRST_TAIL.n0 5.32067
R7750 XCAP.E_PRST_TAIL.n7 XCAP.E_PRST_TAIL.t1 0.228
R7751 XCAP.E_PRST_TAIL.n7 XCAP.E_PRST_TAIL.t0 0.228
R7752 XCAP.E_PRST_TAIL.n8 XCAP.E_PRST_TAIL.t11 0.228
R7753 XCAP.E_PRST_TAIL.n8 XCAP.E_PRST_TAIL.t10 0.228
R7754 XCAP.E_PRST_TAIL.n4 XCAP.E_PRST_TAIL.t7 0.228
R7755 XCAP.E_PRST_TAIL.n4 XCAP.E_PRST_TAIL.t8 0.228
R7756 XCAP.E_PRST_TAIL.n2 XCAP.E_PRST_TAIL.t5 0.228
R7757 XCAP.E_PRST_TAIL.n2 XCAP.E_PRST_TAIL.t6 0.228
R7758 XCAP.E_PRST_TAIL.n0 XCAP.E_PRST_TAIL.t3 0.228
R7759 XCAP.E_PRST_TAIL.n0 XCAP.E_PRST_TAIL.t4 0.228
R7760 XCAP.E_PRST_TAIL.n3 XCAP.E_PRST_TAIL.n1 0.189974
R7761 XCAP.E_PRST_TAIL.n5 XCAP.E_PRST_TAIL.n3 0.189974
R7762 XCAP.E_PRST_TAIL.n6 XCAP.E_PRST_TAIL.n5 0.189974
R7763 XCAP.E_PRST_TAIL XCAP.E_PRST_TAIL.n10 0.0396304
R7764 XCAP.E_QBI.n0 XCAP.E_QBI.t19 113.632
R7765 XCAP.E_QBI.n15 XCAP.E_QBI.t12 113.618
R7766 XCAP.E_QBI.n15 XCAP.E_QBI.t13 113.618
R7767 XCAP.E_QBI.n13 XCAP.E_QBI.t16 113.618
R7768 XCAP.E_QBI.n13 XCAP.E_QBI.t17 113.618
R7769 XCAP.E_QBI.n0 XCAP.E_QBI.t18 113.603
R7770 XCAP.E_QBI.n1 XCAP.E_QBI.t15 61.4885
R7771 XCAP.E_QBI.n1 XCAP.E_QBI.t14 61.4598
R7772 XCAP.E_QBI.n2 XCAP.E_QBI.n0 21.4318
R7773 XCAP.E_QBI.n16 XCAP.E_QBI.n15 17.2548
R7774 XCAP.E_QBI.n2 XCAP.E_QBI.n1 16.3449
R7775 XCAP.E_QBI.n14 XCAP.E_QBI.n13 16.0613
R7776 XCAP.E_QBI.n14 XCAP.E_QBI.n12 14.0679
R7777 XCAP.E_QBI.n10 XCAP.E_QBI.n2 10.194
R7778 XCAP.E_QBI.n5 XCAP.E_QBI.n3 9.3918
R7779 XCAP.E_QBI.n9 XCAP.E_QBI.n8 7.08311
R7780 XCAP.E_QBI.n7 XCAP.E_QBI.t10 5.7796
R7781 XCAP.E_QBI.n4 XCAP.E_QBI.t9 5.7796
R7782 XCAP.E_QBI.n3 XCAP.E_QBI.t7 5.73764
R7783 XCAP.E_QBI.n12 XCAP.E_QBI.t0 5.73764
R7784 XCAP.E_QBI.n12 XCAP.E_QBI.t5 5.73764
R7785 XCAP.E_QBI.n8 XCAP.E_QBI.t3 5.68486
R7786 XCAP.E_QBI.n4 XCAP.E_QBI.t8 5.59012
R7787 XCAP.E_QBI.n3 XCAP.E_QBI.t6 5.54817
R7788 XCAP.E_QBI.n7 XCAP.E_QBI.n6 5.38537
R7789 XCAP.E_QBI.n12 XCAP.E_QBI.n11 5.32067
R7790 XCAP.E_QBI.n5 XCAP.E_QBI.n4 4.5005
R7791 XCAP.E_QBI.n10 XCAP.E_QBI.n9 4.5005
R7792 XCAP.E_QBI.n17 XCAP.E_QBI.n16 4.5005
R7793 XCAP.E_QBI.n16 XCAP.E_QBI.n14 3.69833
R7794 XCAP.E_QBI.n17 XCAP.E_QBI.n10 2.1918
R7795 XCAP.E_QBI.n9 XCAP.E_QBI.n5 0.352674
R7796 XCAP.E_QBI.n11 XCAP.E_QBI.t4 0.228
R7797 XCAP.E_QBI.n11 XCAP.E_QBI.t1 0.228
R7798 XCAP.E_QBI.n6 XCAP.E_QBI.t2 0.20525
R7799 XCAP.E_QBI.n6 XCAP.E_QBI.t11 0.20525
R7800 XCAP.E_QBI.n8 XCAP.E_QBI.n7 0.0952368
R7801 XCAP.E_QBI XCAP.E_QBI.n17 0.0396304
R7802 XCAP.ODD_D_BUF.n19 XCAP.ODD_D_BUF.t12 113.632
R7803 XCAP.ODD_D_BUF.n12 XCAP.ODD_D_BUF.t19 113.632
R7804 XCAP.ODD_D_BUF.n22 XCAP.ODD_D_BUF.t15 109.174
R7805 XCAP.ODD_D_BUF.n21 XCAP.ODD_D_BUF.t14 109.174
R7806 XCAP.ODD_D_BUF.n20 XCAP.ODD_D_BUF.t13 109.174
R7807 XCAP.ODD_D_BUF.n15 XCAP.ODD_D_BUF.t16 109.174
R7808 XCAP.ODD_D_BUF.n14 XCAP.ODD_D_BUF.t17 109.174
R7809 XCAP.ODD_D_BUF.n13 XCAP.ODD_D_BUF.t18 109.174
R7810 XCAP.ODD_D_BUF.n24 XCAP.ODD_D_BUF.n23 23.4289
R7811 XCAP.ODD_D_BUF.n17 XCAP.ODD_D_BUF.n16 20.1159
R7812 XCAP.ODD_D_BUF.n23 XCAP.ODD_D_BUF.n22 18.4942
R7813 XCAP.ODD_D_BUF.n21 XCAP.ODD_D_BUF.n18 18.4942
R7814 XCAP.ODD_D_BUF.n16 XCAP.ODD_D_BUF.n15 18.4942
R7815 XCAP.ODD_D_BUF.n14 XCAP.ODD_D_BUF.n11 18.4942
R7816 XCAP.ODD_D_BUF.n22 XCAP.ODD_D_BUF.n21 11.6805
R7817 XCAP.ODD_D_BUF.n21 XCAP.ODD_D_BUF.n20 11.6805
R7818 XCAP.ODD_D_BUF.n15 XCAP.ODD_D_BUF.n14 11.6805
R7819 XCAP.ODD_D_BUF.n14 XCAP.ODD_D_BUF.n13 11.6805
R7820 XCAP.ODD_D_BUF.n10 XCAP.ODD_D_BUF.n2 10.3701
R7821 XCAP.ODD_D_BUF.n17 XCAP.ODD_D_BUF.n10 8.45267
R7822 XCAP.ODD_D_BUF.n19 XCAP.ODD_D_BUF.n18 7.17687
R7823 XCAP.ODD_D_BUF.n12 XCAP.ODD_D_BUF.n11 7.17687
R7824 XCAP.ODD_D_BUF.n1 XCAP.ODD_D_BUF.t11 5.7796
R7825 XCAP.ODD_D_BUF.n4 XCAP.ODD_D_BUF.t7 5.73764
R7826 XCAP.ODD_D_BUF.n8 XCAP.ODD_D_BUF.t0 5.73764
R7827 XCAP.ODD_D_BUF.n2 XCAP.ODD_D_BUF.t8 5.68486
R7828 XCAP.ODD_D_BUF.n1 XCAP.ODD_D_BUF.n0 5.38537
R7829 XCAP.ODD_D_BUF.n4 XCAP.ODD_D_BUF.n3 5.32067
R7830 XCAP.ODD_D_BUF.n6 XCAP.ODD_D_BUF.n5 5.32067
R7831 XCAP.ODD_D_BUF.n8 XCAP.ODD_D_BUF.n7 5.32067
R7832 XCAP.ODD_D_BUF.n10 XCAP.ODD_D_BUF.n9 4.5005
R7833 XCAP.ODD_D_BUF.n20 XCAP.ODD_D_BUF.n19 4.42851
R7834 XCAP.ODD_D_BUF.n13 XCAP.ODD_D_BUF.n12 4.42851
R7835 XCAP.ODD_D_BUF.n24 XCAP.ODD_D_BUF.n17 3.75702
R7836 XCAP.ODD_D_BUF.n3 XCAP.ODD_D_BUF.t5 0.228
R7837 XCAP.ODD_D_BUF.n3 XCAP.ODD_D_BUF.t6 0.228
R7838 XCAP.ODD_D_BUF.n5 XCAP.ODD_D_BUF.t3 0.228
R7839 XCAP.ODD_D_BUF.n5 XCAP.ODD_D_BUF.t4 0.228
R7840 XCAP.ODD_D_BUF.n7 XCAP.ODD_D_BUF.t1 0.228
R7841 XCAP.ODD_D_BUF.n7 XCAP.ODD_D_BUF.t2 0.228
R7842 XCAP.ODD_D_BUF.n0 XCAP.ODD_D_BUF.t9 0.20525
R7843 XCAP.ODD_D_BUF.n0 XCAP.ODD_D_BUF.t10 0.20525
R7844 XCAP.ODD_D_BUF.n6 XCAP.ODD_D_BUF.n4 0.189974
R7845 XCAP.ODD_D_BUF.n23 XCAP.ODD_D_BUF.n18 0.1205
R7846 XCAP.ODD_D_BUF.n16 XCAP.ODD_D_BUF.n11 0.1205
R7847 XCAP.ODD_D_BUF.n9 XCAP.ODD_D_BUF.n8 0.0952368
R7848 XCAP.ODD_D_BUF.n9 XCAP.ODD_D_BUF.n6 0.0952368
R7849 XCAP.ODD_D_BUF.n2 XCAP.ODD_D_BUF.n1 0.0952368
R7850 XCAP.ODD_D_BUF XCAP.ODD_D_BUF.n24 0.0396304
R7851 XCAP.EVEN_D_BUF.n1 XCAP.EVEN_D_BUF.t12 113.632
R7852 XCAP.EVEN_D_BUF.n7 XCAP.EVEN_D_BUF.t16 113.632
R7853 XCAP.EVEN_D_BUF.n4 XCAP.EVEN_D_BUF.t15 109.174
R7854 XCAP.EVEN_D_BUF.n3 XCAP.EVEN_D_BUF.t14 109.174
R7855 XCAP.EVEN_D_BUF.n2 XCAP.EVEN_D_BUF.t13 109.174
R7856 XCAP.EVEN_D_BUF.n8 XCAP.EVEN_D_BUF.t17 109.174
R7857 XCAP.EVEN_D_BUF.n9 XCAP.EVEN_D_BUF.t18 109.174
R7858 XCAP.EVEN_D_BUF.n10 XCAP.EVEN_D_BUF.t19 109.174
R7859 XCAP.EVEN_D_BUF.n12 XCAP.EVEN_D_BUF.n5 25.855
R7860 XCAP.EVEN_D_BUF.n12 XCAP.EVEN_D_BUF.n11 20.5437
R7861 XCAP.EVEN_D_BUF.n5 XCAP.EVEN_D_BUF.n4 18.4942
R7862 XCAP.EVEN_D_BUF.n3 XCAP.EVEN_D_BUF.n0 18.4942
R7863 XCAP.EVEN_D_BUF.n9 XCAP.EVEN_D_BUF.n6 18.4942
R7864 XCAP.EVEN_D_BUF.n11 XCAP.EVEN_D_BUF.n10 18.4942
R7865 XCAP.EVEN_D_BUF.n4 XCAP.EVEN_D_BUF.n3 11.6805
R7866 XCAP.EVEN_D_BUF.n3 XCAP.EVEN_D_BUF.n2 11.6805
R7867 XCAP.EVEN_D_BUF.n9 XCAP.EVEN_D_BUF.n8 11.6805
R7868 XCAP.EVEN_D_BUF.n10 XCAP.EVEN_D_BUF.n9 11.6805
R7869 XCAP.EVEN_D_BUF.n23 XCAP.EVEN_D_BUF.n22 10.3309
R7870 XCAP.EVEN_D_BUF.n1 XCAP.EVEN_D_BUF.n0 7.17687
R7871 XCAP.EVEN_D_BUF.n7 XCAP.EVEN_D_BUF.n6 7.17687
R7872 XCAP.EVEN_D_BUF.n21 XCAP.EVEN_D_BUF.t11 5.7796
R7873 XCAP.EVEN_D_BUF.n14 XCAP.EVEN_D_BUF.t7 5.73764
R7874 XCAP.EVEN_D_BUF.n18 XCAP.EVEN_D_BUF.t0 5.73764
R7875 XCAP.EVEN_D_BUF.n22 XCAP.EVEN_D_BUF.t8 5.68486
R7876 XCAP.EVEN_D_BUF.n21 XCAP.EVEN_D_BUF.n20 5.38537
R7877 XCAP.EVEN_D_BUF.n14 XCAP.EVEN_D_BUF.n13 5.32067
R7878 XCAP.EVEN_D_BUF.n16 XCAP.EVEN_D_BUF.n15 5.32067
R7879 XCAP.EVEN_D_BUF.n18 XCAP.EVEN_D_BUF.n17 5.32067
R7880 XCAP.EVEN_D_BUF.n23 XCAP.EVEN_D_BUF.n19 4.53963
R7881 XCAP.EVEN_D_BUF.n24 XCAP.EVEN_D_BUF.n23 4.5005
R7882 XCAP.EVEN_D_BUF.n2 XCAP.EVEN_D_BUF.n1 4.42851
R7883 XCAP.EVEN_D_BUF.n8 XCAP.EVEN_D_BUF.n7 4.42851
R7884 XCAP.EVEN_D_BUF.n24 XCAP.EVEN_D_BUF.n12 3.91354
R7885 XCAP.EVEN_D_BUF.n13 XCAP.EVEN_D_BUF.t5 0.228
R7886 XCAP.EVEN_D_BUF.n13 XCAP.EVEN_D_BUF.t6 0.228
R7887 XCAP.EVEN_D_BUF.n15 XCAP.EVEN_D_BUF.t3 0.228
R7888 XCAP.EVEN_D_BUF.n15 XCAP.EVEN_D_BUF.t4 0.228
R7889 XCAP.EVEN_D_BUF.n17 XCAP.EVEN_D_BUF.t1 0.228
R7890 XCAP.EVEN_D_BUF.n17 XCAP.EVEN_D_BUF.t2 0.228
R7891 XCAP.EVEN_D_BUF.n20 XCAP.EVEN_D_BUF.t9 0.20525
R7892 XCAP.EVEN_D_BUF.n20 XCAP.EVEN_D_BUF.t10 0.20525
R7893 XCAP.EVEN_D_BUF.n16 XCAP.EVEN_D_BUF.n14 0.189974
R7894 XCAP.EVEN_D_BUF.n5 XCAP.EVEN_D_BUF.n0 0.1205
R7895 XCAP.EVEN_D_BUF.n11 XCAP.EVEN_D_BUF.n6 0.1205
R7896 XCAP.EVEN_D_BUF.n19 XCAP.EVEN_D_BUF.n18 0.0952368
R7897 XCAP.EVEN_D_BUF.n19 XCAP.EVEN_D_BUF.n16 0.0952368
R7898 XCAP.EVEN_D_BUF.n22 XCAP.EVEN_D_BUF.n21 0.0952368
R7899 XCAP.EVEN_D_BUF XCAP.EVEN_D_BUF.n24 0.0396304
C0 XFRONT.XFE_O.SB SAMP_O_P 0.04213f
C1 XFRONT.XFE_O.BN FE_O_N 3.20364f
C2 RXP TERM_EN1_N 0.30522f
C3 XCAP.E_PRST_TAIL EVEN_QB 0.0844f
C4 XFRONT.XFE_O.BN O_REGEN_CLK 0.12159f
C5 SAMP_CLK_P SAMP_BIAS 2.0425f
C6 XFRONT.XFE_O.SA SAMP_O_P 0.90873f
C7 XFRONT.XFE_O.SXN FE_O_N 0.13551f
C8 E_CAPTURE_CLKB FE_E_P 0.28347f
C9 XFRONT.XFE_O.NREGEN O_REGEN_CLKB 0.18411f
C10 VDD EVEN_Q 7.31561f
C11 XCAP.E_QBI EVEN_QB 0.15538f
C12 XFRONT.XFE_O.SXN O_REGEN_CLK 0.28429f
C13 XFRONT.XFE_E.XP E_REGEN_CLKB 0.41303f
C14 SAMP_E_P E_SENSE_BOOST 0.06659f
C15 E_SENSE_CLK SAMP_E_N 0.30032f
C16 O_REGEN_CLK O_SENSE_CLK 0.05769f
C17 XFRONT.XFE_E.SXP E_REGEN_CLK 0.39898f
C18 SAMP_O_P RX_RESTP 0.10098f
C19 XFRONT.XFE_O.BN VDD 6.76697f
C20 XCAP.O_QBBUF ODD_Q 4.18276f
C21 XCAP.O_QBI ODD_QB 0.15666f
C22 XFRONT.XFE_O.SXP O_REGEN_CLK 0.39898f
C23 O_CAPTURE_CLKB ODD_Q 0.07511f
C24 XFRONT.XFE_E.XN E_REGEN_CLKB 0.27371f
C25 VDD RXP 0.72204f
C26 XCAP.EVEN_D_BUF E_CAPTURE_CLK 0.10379f
C27 XFRONT.XFE_E.SXN E_REGEN_CLK 0.28429f
C28 XFRONT.XFE_E.NTAIL SAMP_E_N 1.1378f
C29 XFRONT.XFE_E.NTAIL E_SENSE_CLK 0.93342f
C30 XFRONT.XFE_O.XN O_REGEN_CLKB 0.27371f
C31 XFRONT.XFE_O.SXN VDD 12.5413f
C32 XCAP.O_PRST_TAIL ODD_QB 0.43511f
C33 XCAP.EVEN_D_BUF EVEN_QB 0.13958f
C34 VDD O_SENSE_CLK 3.1142f
C35 SAMP_O_N O_SENSE_BOOST 0.06659f
C36 XCAP.O_QI O_CAPTURE_CLK 0.16467f
C37 XFRONT.XFE_E.BN E_REGEN_CLK 0.12159f
C38 RXP TERM_EN0_N 0.29398f
C39 XFRONT.XFE_O.XP O_REGEN_CLKB 0.41303f
C40 XFRONT.XFE_O.SXP VDD 12.5687f
C41 XCAP.EVEN_DB_BUF FE_E_N 0.03785f
C42 VDD E_CAPTURE_CLK 2.30838f
C43 XCAP.ODD_DB_BUF O_CAPTURE_CLK 0.32291f
C44 XCAP.E_PSET_TAIL E_CAPTURE_CLKB 3.32426f
C45 VDD EVEN_QB 8.86516f
C46 XFRONT.XFE_O.BP VDD 6.76837f
C47 XCAP.E_QI FE_E_N 0.52886f
C48 XCAP.O_SET_TAIL XCAP.O_RST_TAIL 0.70351f
C49 XFRONT.XFE_O.NTAIL O_SENSE_CLK 0.93342f
C50 XFRONT.XFE_E.NREGEN E_REGEN_CLK 2.24204f
C51 XFRONT.XFE_E.BP VDD 6.76837f
C52 XCAP.ODD_D_BUF ODD_QB 0.15391f
C53 VDD SAMP_E_P 0.26142f
C54 ODD_QB FE_O_N 0.09326f
C55 XFRONT.XFE_O.VREGN O_REGEN_CLKB 2.28169f
C56 XFRONT.XFE_E.SXP VDD 12.5687f
C57 XCAP.E_SET_TAIL XCAP.E_RST_TAIL 0.57545f
C58 XFRONT.XFE_E.VREGP E_REGEN_CLKB 3.66341f
C59 TERM_EN6_N TERM_EN5_N 0.0465f
C60 XFRONT.XFE_O.SXN XFRONT.XFE_O.BN 2.55502f
C61 XCAP.EVEN_DB_BUF E_CAPTURE_CLKB 0.19022f
C62 FE_O_P O_CAPTURE_CLK 0.2426f
C63 O_CAPTURE_CLKB O_CAPTURE_CLK 3.07408f
C64 XFRONT.XFE_O.SB O_REGEN_CLKB 0.16909f
C65 XFRONT.XFE_E.SXN VDD 12.5413f
C66 XFRONT.XFE_O.NREGEN O_REGEN_CLK 2.24204f
C67 EVEN_Q EVEN_QB 0.47433f
C68 XFRONT.XFE_E.SA E_REGEN_CLKB 0.23634f
C69 XCAP.E_QI E_CAPTURE_CLKB 0.15555f
C70 XFRONT.XFE_E.XP E_REGEN_CLK 2.97989f
C71 SAMP_E_P SAMP_E_N 5.05443f
C72 E_SENSE_CLK SAMP_E_P 5.05623f
C73 XFRONT.XFE_O.SA O_REGEN_CLKB 0.23634f
C74 VDD ODD_QB 7.42733f
C75 XFRONT.XFE_E.BN VDD 6.76697f
C76 XCAP.E_QBBUF FE_E_N 0.14911f
C77 O_CAPTURE_CLK O_REGEN_CLKB 0.03197f
C78 XCAP.O_QI XCAP.O_RST_TAIL 4.94403f
C79 XFRONT.XFE_E.SB E_REGEN_CLKB 0.16909f
C80 VDD SAMP_O_N 0.35499f
C81 XFRONT.XFE_E.XN E_REGEN_CLK 2.93387f
C82 XFRONT.XFE_O.VREGP O_REGEN_CLKB 3.66341f
C83 XFRONT.XFE_O.NREGEN VDD 9.02169f
C84 XFRONT.XFE_E.NTAIL SAMP_E_P 1.30545f
C85 XCAP.ODD_DB_BUF XCAP.O_RST_TAIL 0.56945f
C86 XFRONT.XFE_O.XN O_REGEN_CLK 2.93387f
C87 XFRONT.XFE_E.VREGN E_REGEN_CLKB 2.28169f
C88 XFRONT.XFE_O.SB O_SENSE_BOOST 0.17061f
C89 XFRONT.XFE_E.NREGEN VDD 9.02169f
C90 VTHP VTHN 1.695f
C91 XCAP.O_QI XCAP.O_SET_TAIL 0.48793f
C92 XFRONT.XFE_O.XP O_REGEN_CLK 2.97989f
C93 XFRONT.XFE_O.BP XFRONT.XFE_O.SXP 2.48339f
C94 XCAP.O_QBI O_CAPTURE_CLK 0.04327f
C95 XFRONT.XFE_O.NTAIL SAMP_O_N 1.30545f
C96 REST_BIAS RX_RAWP 0.25868f
C97 XFRONT.XFE_O.SA O_SENSE_BOOST 0.04435f
C98 XFRONT.XFE_O.XN VDD 23.0487f
C99 XCAP.ODD_DB_BUF XCAP.O_SET_TAIL 0.54226f
C100 XCAP.EVEN_DB_BUF XCAP.E_RST_TAIL 0.50524f
C101 XFRONT.XFE_O.NREGEN XFRONT.XFE_O.NTAIL 0.05705f
C102 XCAP.E_QBBUF E_CAPTURE_CLKB 0.15018f
C103 XCAP.EVEN_DB_BUF FE_E_P 3.50536f
C104 FE_E_P E_REGEN_CLKB 0.19768f
C105 XFRONT.XFE_E.NREGEN SAMP_E_N 0.0139f
C106 XFRONT.XFE_E.NREGEN E_SENSE_CLK 0.11224f
C107 VDD ODD_Q 7.41927f
C108 XFRONT.XFE_O.XP VDD 24.8188f
C109 XCAP.O_QI XCAP.O_PSET_TAIL 5.10737f
C110 XCAP.E_QI XCAP.E_RST_TAIL 4.88428f
C111 XCAP.O_RST_TAIL FE_O_P 0.16401f
C112 XCAP.E_QI FE_E_P 0.09054f
C113 XFRONT.XFE_E.XP VDD 24.8188f
C114 XCAP.ODD_DB_BUF XCAP.O_PSET_TAIL 0.68175f
C115 XCAP.EVEN_DB_BUF XCAP.E_SET_TAIL 0.71109f
C116 XFRONT.XFE_E.NREGEN XFRONT.XFE_E.NTAIL 0.05705f
C117 TERM_EN5_N TERM_EN4_N 0.0465f
C118 O_SENSE_CLK SAMP_O_N 5.05623f
C119 XFRONT.XFE_E.XN VDD 23.0487f
C120 XCAP.EVEN_D_BUF FE_E_N 3.45509f
C121 XCAP.E_QI XCAP.E_SET_TAIL 0.76857f
C122 XFRONT.XFE_O.SB O_REGEN_CLK 0.27286f
C123 XCAP.ODD_D_BUF O_CAPTURE_CLK 0.0367f
C124 XFRONT.XFE_E.SXP XFRONT.XFE_E.BP 2.48339f
C125 XFRONT.XFE_O.NREGEN XFRONT.XFE_O.SXN 1.12793f
C126 XCAP.E_PRST_TAIL E_CAPTURE_CLKB 0.94605f
C127 XFRONT.XFE_O.NREGEN O_SENSE_CLK 0.11224f
C128 XFRONT.XFE_E.SA E_SENSE_BOOST 0.04435f
C129 XFRONT.XFE_E.SA E_REGEN_CLK 0.34023f
C130 XFRONT.XFE_E.XP E_SENSE_CLK 0.15824f
C131 XFRONT.XFE_O.VREGN VDD 12.591f
C132 VDD RX_RESTN 0.41275f
C133 FE_O_N O_CAPTURE_CLK 0.52071f
C134 XCAP.EVEN_DB_BUF XCAP.E_PSET_TAIL 1.81361f
C135 XFRONT.XFE_O.SA O_REGEN_CLK 0.34023f
C136 XCAP.ODD_DB_BUF XCAP.O_QI 3.71826f
C137 XFRONT.XFE_O.NREGEN XFRONT.XFE_O.SXP 0.43552f
C138 O_CAPTURE_CLK O_REGEN_CLK 0.0157f
C139 XCAP.E_QBI E_CAPTURE_CLKB 0.12357f
C140 XFRONT.XFE_E.SB E_SENSE_BOOST 0.17061f
C141 XFRONT.XFE_E.SB E_REGEN_CLK 0.27286f
C142 XFRONT.XFE_E.XN E_SENSE_CLK 1.26026f
C143 XFRONT.XFE_E.XN SAMP_E_N 0.02387f
C144 VDD FE_E_N 14.2791f
C145 XFRONT.XFE_O.SB VDD 6.44275f
C146 XCAP.E_QI XCAP.E_PSET_TAIL 5.13429f
C147 XCAP.O_QBI XCAP.O_RST_TAIL 0.0736f
C148 XFRONT.XFE_O.XN XFRONT.XFE_O.SXN 1.52306f
C149 XCAP.O_PSET_TAIL O_CAPTURE_CLKB 2.02608f
C150 RX_RESTN SAMP_CLK_N 0.09294f
C151 XFRONT.XFE_O.XN O_SENSE_CLK 1.26026f
C152 SAMP_E_N RX_RESTN 0.21698f
C153 XFRONT.XFE_O.SA VDD 7.16352f
C154 VDD O_CAPTURE_CLK 2.30876f
C155 XCAP.O_QBUF XCAP.O_PSET_TAIL 0.04525f
C156 XFRONT.XFE_O.XP XFRONT.XFE_O.SXN 0.18968f
C157 XCAP.EVEN_D_BUF E_CAPTURE_CLKB 0.42228f
C158 XFRONT.XFE_O.XP O_SENSE_CLK 0.15824f
C159 XFRONT.XFE_O.VREGP VDD 13.9312f
C160 VDD RX_RESTP 0.38423f
C161 XCAP.O_QBBUF XCAP.O_QI 0.68141f
C162 XCAP.O_QBI XCAP.O_SET_TAIL 4.91815f
C163 XCAP.O_QI FE_O_P 0.12934f
C164 XFRONT.XFE_O.XP XFRONT.XFE_O.SXP 2.28757f
C165 XFRONT.XFE_E.BN XFRONT.XFE_E.SXN 2.55502f
C166 XCAP.O_QI O_CAPTURE_CLKB 0.15737f
C167 XFRONT.XFE_O.SB XFRONT.XFE_O.NTAIL 2.81419f
C168 XFRONT.XFE_E.VREGP VDD 13.9312f
C169 FE_E_P E_REGEN_CLK 0.28385f
C170 REST_BIAS RX_RAWN 0.11711f
C171 XFRONT.XFE_E.NREGEN SAMP_E_P 0.01317f
C172 VDD E_CAPTURE_CLKB 10.4761f
C173 XCAP.E_QI XCAP.EVEN_DB_BUF 3.57751f
C174 XCAP.ODD_DB_BUF FE_O_P 3.64424f
C175 XFRONT.XFE_O.SA XFRONT.XFE_O.NTAIL 3.62199f
C176 XFRONT.XFE_E.NREGEN XFRONT.XFE_E.SXP 0.43552f
C177 XCAP.ODD_DB_BUF O_CAPTURE_CLKB 0.81461f
C178 RX_RESTP SAMP_CLK_N 0.02351f
C179 SAMP_E_N RX_RESTP 0.17266f
C180 XFRONT.XFE_E.SA VDD 7.16352f
C181 XCAP.O_QBI XCAP.O_PSET_TAIL 0.30508f
C182 XCAP.ODD_D_BUF XCAP.O_RST_TAIL 0.70292f
C183 XCAP.E_QBI XCAP.E_RST_TAIL 0.01355f
C184 SAMP_O_P O_SENSE_BOOST 0.05905f
C185 XFRONT.XFE_E.NREGEN XFRONT.XFE_E.SXN 1.12793f
C186 XFRONT.XFE_O.VREGN XFRONT.XFE_O.SXN 0.01502f
C187 XFRONT.XFE_O.NREGEN SAMP_O_N 0.01317f
C188 TERM_EN4_N TERM_EN3_N 0.0465f
C189 XFRONT.XFE_E.SB VDD 6.44275f
C190 XCAP.O_PRST_TAIL XCAP.O_PSET_TAIL 1.05443f
C191 XFRONT.XFE_O.SB O_SENSE_CLK 1.27971f
C192 XFRONT.XFE_E.SA SAMP_E_N 0.90873f
C193 XFRONT.XFE_E.SA E_SENSE_CLK 2.78252f
C194 XFRONT.XFE_E.VREGN VDD 12.591f
C195 XFRONT.XFE_E.XP SAMP_E_P 0.01394f
C196 XCAP.ODD_D_BUF XCAP.O_SET_TAIL 0.53742f
C197 XCAP.O_QBI XCAP.O_QI 8.49253f
C198 XCAP.EVEN_D_BUF XCAP.E_RST_TAIL 0.37995f
C199 XCAP.E_QBI XCAP.E_SET_TAIL 4.91367f
C200 XFRONT.XFE_E.XP XFRONT.XFE_E.SXP 2.28757f
C201 XFRONT.XFE_O.SB XFRONT.XFE_O.SXP 0.01479f
C202 XCAP.O_QBBUF O_CAPTURE_CLKB 0.16758f
C203 RX_RAWP RX_RAWN 0.58235f
C204 FE_E_N E_CAPTURE_CLK 0.57071f
C205 SAMP_CLK_P SAMP_CLK_N 2.34225f
C206 XFRONT.XFE_O.SA O_SENSE_CLK 2.78252f
C207 E_CAPTURE_CLKB EVEN_Q 0.10117f
C208 VDD VTHP 0.93005f
C209 XCAP.EVEN_D_BUF FE_E_P 0.04189f
C210 XFRONT.XFE_E.SB E_SENSE_CLK 1.27971f
C211 XFRONT.XFE_E.SB SAMP_E_N 0.04213f
C212 EVEN_QB FE_E_N 0.06902f
C213 ODD_QB ODD_Q 0.51937f
C214 XCAP.O_PRST_TAIL XCAP.O_QI 0.29363f
C215 XCAP.O_QBI XCAP.ODD_DB_BUF 0.19065f
C216 XCAP.E_QBUF XCAP.E_QI 0.06057f
C217 XCAP.E_PRST_TAIL XCAP.E_PSET_TAIL 1.95856f
C218 VDD TERM_EN6_N 1.78028f
C219 XFRONT.XFE_E.SA XFRONT.XFE_E.NTAIL 3.62199f
C220 XFRONT.XFE_O.XN XFRONT.XFE_O.NREGEN 15.2443f
C221 XFRONT.XFE_E.XP XFRONT.XFE_E.SXN 0.18968f
C222 SAMP_CLK_N SAMP_BIAS 1.47664f
C223 XFRONT.XFE_O.XP SAMP_O_N 0.01394f
C224 XFRONT.XFE_E.BP FE_E_N 2.97395f
C225 XCAP.ODD_D_BUF XCAP.O_PSET_TAIL 1.09217f
C226 XCAP.E_QBBUF XCAP.E_QI 0.60128f
C227 XCAP.EVEN_D_BUF XCAP.E_SET_TAIL 0.61506f
C228 XCAP.O_PRST_TAIL XCAP.ODD_DB_BUF 0.86137f
C229 XCAP.E_QBI XCAP.E_PSET_TAIL 0.20078f
C230 SAMP_E_P RX_RESTN 0.42621f
C231 XFRONT.XFE_E.SB XFRONT.XFE_E.NTAIL 2.81419f
C232 XFRONT.XFE_O.XP XFRONT.XFE_O.NREGEN 15.5907f
C233 XFRONT.XFE_E.XN XFRONT.XFE_E.SXN 1.52306f
C234 XFRONT.XFE_O.VREGP XFRONT.XFE_O.SXP 0.03789f
C235 RX_BW_EN_N VTHP 0.14804f
C236 VDD FE_E_P 14.5006f
C237 E_REGEN_CLKB E_REGEN_CLK 5.87024f
C238 VDD REST_BIAS 0.20996f
C239 E_CAPTURE_CLKB E_CAPTURE_CLK 2.90086f
C240 XCAP.ODD_D_BUF XCAP.O_QI 0.70423f
C241 XCAP.E_PRST_TAIL XCAP.EVEN_DB_BUF 0.13174f
C242 XCAP.EVEN_D_BUF XCAP.E_PSET_TAIL 0.4182f
C243 XFRONT.XFE_O.XP XFRONT.XFE_O.XN 18.0183f
C244 XFRONT.XFE_E.XP XFRONT.XFE_E.NREGEN 15.5907f
C245 XCAP.O_QBI O_CAPTURE_CLKB 0.07731f
C246 VDD SAMP_O_P 0.35499f
C247 E_CAPTURE_CLKB EVEN_QB 0.70057f
C248 SAMP_O_N RX_RESTN 0.01966f
C249 VDD TERM_EN5_N 1.84084f
C250 XCAP.O_QI FE_O_N 0.57789f
C251 XCAP.O_PSET_TAIL VDD 13.1964f
C252 XCAP.ODD_D_BUF XCAP.ODD_DB_BUF 1.07149f
C253 XCAP.O_QBI XCAP.O_QBUF 1.08164f
C254 XCAP.E_QBI XCAP.EVEN_DB_BUF 0.0643f
C255 XCAP.E_PRST_TAIL XCAP.E_QI 0.2741f
C256 SAMP_E_P RX_RESTP 0.05468f
C257 XFRONT.XFE_E.XN XFRONT.XFE_E.NREGEN 15.2443f
C258 XCAP.O_PRST_TAIL O_CAPTURE_CLKB 3.41065f
C259 XFRONT.XFE_O.SB SAMP_O_N 0.77892f
C260 RXP TERM_EN6_N 0.32905f
C261 XCAP.E_PSET_TAIL VDD 11.6748f
C262 XCAP.O_PRST_TAIL XCAP.O_QBUF 1.54979f
C263 XCAP.E_QBI XCAP.E_QI 8.54354f
C264 TERM_EN3_N TERM_EN2_N 0.0465f
C265 XFRONT.XFE_O.SB XFRONT.XFE_O.NREGEN 2.22508f
C266 XFRONT.XFE_E.VREGP XFRONT.XFE_E.SXP 0.03789f
C267 XFRONT.XFE_O.NTAIL SAMP_O_P 1.1378f
C268 XFRONT.XFE_O.SA SAMP_O_N 0.05427f
C269 VDD RX_RAWP 1.26797f
C270 XCAP.O_QI VDD 7.2336f
C271 XFRONT.XFE_E.SA SAMP_E_P 0.05427f
C272 XCAP.EVEN_D_BUF XCAP.EVEN_DB_BUF 0.97829f
C273 XFRONT.XFE_O.VREGN XFRONT.XFE_O.XN 9.76051f
C274 XFRONT.XFE_O.SA XFRONT.XFE_O.NREGEN 2.62097f
C275 SAMP_O_N RX_RESTP 0.21629f
C276 XCAP.ODD_DB_BUF VDD 13.0218f
C277 XFRONT.XFE_E.SB SAMP_E_P 0.77892f
C278 XCAP.E_PRST_TAIL XCAP.E_QBUF 0.53754f
C279 XCAP.ODD_D_BUF XCAP.O_QBBUF 2.37715f
C280 XCAP.EVEN_D_BUF XCAP.E_QI 0.74882f
C281 XFRONT.XFE_O.VREGP XFRONT.XFE_O.NREGEN 0.01091f
C282 XFRONT.XFE_E.SB XFRONT.XFE_E.SXP 0.01479f
C283 XFRONT.XFE_E.XN XFRONT.XFE_E.XP 18.0183f
C284 XFRONT.XFE_O.VREGN XFRONT.XFE_O.XP 1.71293f
C285 XCAP.ODD_D_BUF FE_O_P 0.02446f
C286 XFRONT.XFE_O.SB XFRONT.XFE_O.XN 3.3005f
C287 XCAP.ODD_D_BUF O_CAPTURE_CLKB 0.70031f
C288 XCAP.E_RST_TAIL E_CAPTURE_CLK 1.16209f
C289 VDD TERM_EN4_N 1.84084f
C290 RX_RAWP RX_BW_EN_N 0.3734f
C291 XCAP.O_QBBUF FE_O_N 0.20592f
C292 XCAP.EVEN_DB_BUF VDD 12.9418f
C293 FE_O_P FE_O_N 2.27142f
C294 FE_E_P E_CAPTURE_CLK 0.4521f
C295 O_CAPTURE_CLKB FE_O_N 0.16304f
C296 VDD E_REGEN_CLKB 17.4356f
C297 XCAP.E_QBI XCAP.E_QBUF 0.99299f
C298 XCAP.ODD_D_BUF XCAP.O_QBUF 0.28842f
C299 XCAP.O_PRST_TAIL XCAP.O_QBI 5.53402f
C300 VDD VTHN 0.51765f
C301 XFRONT.XFE_O.SA XFRONT.XFE_O.XN 2.02785f
C302 XFRONT.XFE_O.SB XFRONT.XFE_O.XP 2.02624f
C303 RXP TERM_EN5_N 0.3225f
C304 EVEN_QB FE_E_P 0.07547f
C305 O_SENSE_CLK SAMP_O_P 0.30032f
C306 RX_BIAS RXN 0.36689f
C307 XCAP.E_QI VDD 7.23216f
C308 XFRONT.XFE_E.VREGN XFRONT.XFE_E.SXN 0.01502f
C309 XFRONT.XFE_E.VREGP XFRONT.XFE_E.NREGEN 0.01091f
C310 XFRONT.XFE_O.SA XFRONT.XFE_O.XP 2.75504f
C311 XFRONT.XFE_O.VREGP XFRONT.XFE_O.XN 1.41685f
C312 XCAP.E_SET_TAIL E_CAPTURE_CLK 1.75694f
C313 FE_O_N O_REGEN_CLKB 0.19768f
C314 E_REGEN_CLKB E_SENSE_CLK 0.01888f
C315 RX_BW_EN_N VTHN 0.52758f
C316 O_REGEN_CLKB O_REGEN_CLK 5.87024f
C317 XCAP.O_QBBUF VDD 6.75866f
C318 VDD FE_O_P 14.3026f
C319 VDD O_CAPTURE_CLKB 10.3115f
C320 XFRONT.XFE_E.SA XFRONT.XFE_E.NREGEN 2.62097f
C321 XFRONT.XFE_O.VREGP XFRONT.XFE_O.XP 9.69939f
C322 XCAP.O_QBUF VDD 6.35692f
C323 VDD TERM_EN3_N 1.84084f
C324 XCAP.EVEN_D_BUF XCAP.E_QBBUF 2.27875f
C325 XCAP.ODD_D_BUF XCAP.O_QBI 4.78972f
C326 XFRONT.XFE_E.SB XFRONT.XFE_E.NREGEN 2.22508f
C327 VDD O_REGEN_CLKB 17.4356f
C328 XFRONT.XFE_E.SXN FE_E_P 0.13551f
C329 XCAP.E_QBUF VDD 7.45153f
C330 XCAP.E_QBI XCAP.E_PRST_TAIL 5.5293f
C331 XCAP.ODD_D_BUF XCAP.O_PRST_TAIL 0.78807f
C332 RXP TERM_EN4_N 0.3225f
C333 XCAP.E_PSET_TAIL EVEN_QB 0.02064f
C334 XFRONT.XFE_E.VREGP XFRONT.XFE_E.XP 9.69939f
C335 TERM_EN2_N TERM_EN1_N 0.0465f
C336 XFRONT.XFE_E.BN FE_E_P 3.20364f
C337 XCAP.E_QBBUF VDD 6.44257f
C338 XFRONT.XFE_O.SA XFRONT.XFE_O.SB 4.61805f
C339 XFRONT.XFE_E.VREGP XFRONT.XFE_E.XN 1.41685f
C340 XFRONT.XFE_E.SA XFRONT.XFE_E.XP 2.75504f
C341 RX_RESTN RX_RESTP 4.19071f
C342 XCAP.O_QBI VDD 8.61871f
C343 XCAP.EVEN_D_BUF XCAP.E_PRST_TAIL 3.77728f
C344 VDD RX_RAWN 1.26797f
C345 XFRONT.XFE_E.SB XFRONT.XFE_E.XP 2.02624f
C346 XFRONT.XFE_E.SA XFRONT.XFE_E.XN 2.02785f
C347 XCAP.EVEN_DB_BUF E_CAPTURE_CLK 0.15269f
C348 E_CAPTURE_CLK E_REGEN_CLKB 0.03197f
C349 VDD TERM_EN2_N 1.84084f
C350 XCAP.O_PRST_TAIL VDD 15.3528f
C351 SAMP_O_P SAMP_O_N 5.12811f
C352 XCAP.EVEN_D_BUF XCAP.E_QBI 4.77076f
C353 XCAP.O_PSET_TAIL ODD_QB 0.21495f
C354 XCAP.EVEN_DB_BUF EVEN_QB 0.15519f
C355 XFRONT.XFE_O.VREGP XFRONT.XFE_O.SA 0.01053f
C356 XFRONT.XFE_E.SB XFRONT.XFE_E.XN 3.3005f
C357 XFRONT.XFE_E.VREGN XFRONT.XFE_E.XP 1.71293f
C358 VDD E_REGEN_CLK 21.5641f
C359 E_CAPTURE_CLKB FE_E_N 0.12139f
C360 XCAP.E_QI E_CAPTURE_CLK 0.1853f
C361 XFRONT.XFE_O.NREGEN SAMP_O_P 0.0139f
C362 RXP TERM_EN3_N 0.3225f
C363 XCAP.ODD_D_BUF FE_O_N 3.44145f
C364 RX_RAWN RX_BW_EN_N 0.3734f
C365 XCAP.E_PRST_TAIL VDD 16.0686f
C366 XFRONT.XFE_O.BN O_REGEN_CLKB 0.10264f
C367 XCAP.E_QBBUF EVEN_Q 4.25991f
C368 XCAP.E_QI EVEN_QB 0.33632f
C369 XFRONT.XFE_E.VREGN XFRONT.XFE_E.XN 9.76051f
C370 XFRONT.XFE_O.NTAIL O_SENSE_BOOST 0.96944f
C371 FE_O_N O_REGEN_CLK 0.28385f
C372 XCAP.E_QBI VDD 8.57345f
C373 XFRONT.XFE_O.SXN O_REGEN_CLKB 0.24469f
C374 SAMP_E_N E_SENSE_BOOST 0.05905f
C375 E_SENSE_CLK E_SENSE_BOOST 4.27044f
C376 O_REGEN_CLKB O_SENSE_CLK 0.01888f
C377 E_REGEN_CLK E_SENSE_CLK 0.05769f
C378 XCAP.O_QI ODD_QB 0.23682f
C379 XFRONT.XFE_E.SXP E_REGEN_CLKB 0.14644f
C380 XFRONT.XFE_O.BP FE_O_P 2.97395f
C381 RXP RXN 0.49155f
C382 XFRONT.XFE_O.XN SAMP_O_P 0.02387f
C383 RX_RESTN SAMP_BIAS 0.01215f
C384 XCAP.ODD_D_BUF VDD 15.601f
C385 XFRONT.XFE_O.SXP O_REGEN_CLKB 0.14644f
C386 XCAP.ODD_DB_BUF ODD_QB 0.17063f
C387 XFRONT.XFE_E.SXN E_REGEN_CLKB 0.24469f
C388 VDD TERM_EN1_N 1.84084f
C389 XFRONT.XFE_E.NTAIL E_SENSE_BOOST 0.96944f
C390 XFRONT.XFE_E.NTAIL E_REGEN_CLK 0.05461f
C391 VDD FE_O_N 14.4285f
C392 XCAP.EVEN_D_BUF VDD 14.4594f
C393 VDD O_REGEN_CLK 21.5641f
C394 XCAP.E_QBUF EVEN_QB 4.13702f
C395 XFRONT.XFE_E.SA XFRONT.XFE_E.VREGP 0.01053f
C396 XFRONT.XFE_E.BN E_REGEN_CLKB 0.10264f
C397 RX_RESTP SAMP_CLK_P 0.38527f
C398 RXP TERM_EN2_N 0.3225f
C399 TERM_EN1_N TERM_EN0_N 0.0465f
C400 O_SENSE_CLK O_SENSE_BOOST 4.27044f
C401 XCAP.E_RST_TAIL FE_E_N 0.046f
C402 XCAP.E_QBBUF EVEN_QB 0.17621f
C403 XCAP.O_RST_TAIL O_CAPTURE_CLK 2.06628f
C404 FE_E_N FE_E_P 3.5147f
C405 XCAP.O_QBBUF ODD_QB 0.15023f
C406 XFRONT.XFE_O.NTAIL O_REGEN_CLK 0.05461f
C407 XFRONT.XFE_E.SB XFRONT.XFE_E.SA 4.61805f
C408 ODD_QB FE_O_P 0.10247f
C409 O_CAPTURE_CLKB ODD_QB 0.10357f
C410 XFRONT.XFE_E.NREGEN E_REGEN_CLKB 0.18411f
C411 RX_BIAS RXP 0.89265f
C412 SAMP_O_P RX_RESTN 0.17429f
C413 E_CAPTURE_CLK E_REGEN_CLK 0.0157f
C414 VDD TERM_EN0_N 1.71963f
C415 XCAP.O_QBUF ODD_QB 4.17728f
C416 XCAP.O_SET_TAIL O_CAPTURE_CLK 1.51208f
C417 VDD RX_BW_EN_N 3.19847f
C418 VDD SAMP_E_N 0.26142f
C419 VDD E_SENSE_CLK 3.1142f
C420 TERM_EN0_N VSS 3.16281f
C421 TERM_EN1_N VSS 2.58106f
C422 TERM_EN2_N VSS 2.56583f
C423 TERM_EN3_N VSS 2.56561f
C424 TERM_EN4_N VSS 2.56561f
C425 TERM_EN5_N VSS 2.56561f
C426 TERM_EN6_N VSS 2.69513f
C427 RXN VSS 15.24638f
C428 RXP VSS 15.17772f
C429 RX_BIAS VSS 13.3368f
C430 VTHN VSS 5.17466f
C431 VTHP VSS 5.04058f
C432 RX_BW_EN_N VSS 4.30524f
C433 RX_RAWN VSS 11.07534f
C434 RX_RAWP VSS 11.20287f
C435 REST_BIAS VSS 10.07665f
C436 SAMP_BIAS VSS 13.87178f
C437 SAMP_CLK_N VSS 9.98147f
C438 SAMP_CLK_P VSS 14.21055f
C439 RX_RESTP VSS 14.02047f
C440 RX_RESTN VSS 13.0766f
C441 O_SENSE_BOOST VSS 7.77215f
C442 SAMP_O_N VSS 23.62455f
C443 SAMP_O_P VSS 21.78121f
C444 E_SENSE_BOOST VSS 7.77215f
C445 SAMP_E_N VSS 21.54272f
C446 SAMP_E_P VSS 23.6221f
C447 O_SENSE_CLK VSS 10.59916f
C448 E_SENSE_CLK VSS 10.59916f
C449 O_REGEN_CLK VSS 13.62457f
C450 E_REGEN_CLK VSS 13.62457f
C451 O_REGEN_CLKB VSS 4.42478f
C452 E_REGEN_CLKB VSS 4.42478f
C453 O_CAPTURE_CLK VSS 27.65829f
C454 E_CAPTURE_CLK VSS 26.77125f
C455 FE_O_N VSS 29.84371f
C456 FE_O_P VSS 36.52533f
C457 FE_E_P VSS 39.02157f
C458 FE_E_N VSS 28.76325f
C459 ODD_Q VSS 5.29541f
C460 ODD_QB VSS 9.73643f
C461 EVEN_QB VSS 9.40271f
C462 EVEN_Q VSS 5.60206f
C463 O_CAPTURE_CLKB VSS 24.58366f
C464 E_CAPTURE_CLKB VSS 27.1192f
C465 VDD VSS 4.69774p
C466 XFRONT.XFE_O.NTAIL VSS 14.09834f
C467 XFRONT.XFE_E.NTAIL VSS 14.6349f
C468 XFRONT.XFE_O.BN VSS 15.10208f
C469 XFRONT.XFE_O.SXN VSS 12.96782f
C470 XFRONT.XFE_O.SXP VSS 13.11247f
C471 XFRONT.XFE_O.BP VSS 14.72881f
C472 XFRONT.XFE_E.BP VSS 15.07135f
C473 XFRONT.XFE_E.SXP VSS 14.89757f
C474 XFRONT.XFE_E.SXN VSS 13.51859f
C475 XFRONT.XFE_E.BN VSS 15.5139f
C476 XFRONT.XFE_O.NREGEN VSS 16.31945f
C477 XFRONT.XFE_E.NREGEN VSS 16.79713f
C478 XFRONT.XFE_O.XN VSS 8.1339f
C479 XFRONT.XFE_O.XP VSS 8.86716f
C480 XFRONT.XFE_E.XP VSS 9.30753f
C481 XFRONT.XFE_E.XN VSS 9.22271f
C482 XFRONT.XFE_O.VREGN VSS 0.31123f
C483 XFRONT.XFE_O.SB VSS 9.74535f
C484 XFRONT.XFE_O.SA VSS 10.5446f
C485 XFRONT.XFE_O.VREGP VSS 0.30873f
C486 XFRONT.XFE_E.VREGP VSS 2.16504f
C487 XFRONT.XFE_E.SA VSS 11.29091f
C488 XFRONT.XFE_E.SB VSS 11.02386f
C489 XFRONT.XFE_E.VREGN VSS 0.31123f
C490 XCAP.O_RST_TAIL VSS 14.07771f
C491 XCAP.E_RST_TAIL VSS 13.39814f
C492 XCAP.O_SET_TAIL VSS 11.53561f
C493 XCAP.E_SET_TAIL VSS 11.52819f
C494 XCAP.O_PSET_TAIL VSS 0.23222f
C495 XCAP.E_PSET_TAIL VSS 0.15708f
C496 XCAP.O_QI VSS 12.92219f
C497 XCAP.ODD_DB_BUF VSS 9.95341f
C498 XCAP.EVEN_DB_BUF VSS 10.21407f
C499 XCAP.E_QI VSS 12.05735f
C500 XCAP.O_QBBUF VSS 5.49643f
C501 XCAP.O_QBUF VSS 5.2576f
C502 XCAP.E_QBUF VSS 5.25384f
C503 XCAP.E_QBBUF VSS 6.1426f
C504 XCAP.O_QBI VSS 10.93681f
C505 XCAP.O_PRST_TAIL VSS 0.25427f
C506 XCAP.E_PRST_TAIL VSS 0.70236f
C507 XCAP.E_QBI VSS 11.57233f
C508 XCAP.ODD_D_BUF VSS 9.0285f
C509 XCAP.EVEN_D_BUF VSS 9.21535f
C510 XCAP.EVEN_D_BUF.n0 VSS 0.33788f
C511 XCAP.EVEN_D_BUF.n1 VSS 0.16701f
C512 XCAP.EVEN_D_BUF.n2 VSS 0.17902f
C513 XCAP.EVEN_D_BUF.n3 VSS 0.17902f
C514 XCAP.EVEN_D_BUF.n4 VSS 0.16919f
C515 XCAP.EVEN_D_BUF.n5 VSS 2.35913f
C516 XCAP.EVEN_D_BUF.n6 VSS 0.33788f
C517 XCAP.EVEN_D_BUF.n7 VSS 0.16701f
C518 XCAP.EVEN_D_BUF.n8 VSS 0.17902f
C519 XCAP.EVEN_D_BUF.n9 VSS 0.17902f
C520 XCAP.EVEN_D_BUF.n10 VSS 0.16919f
C521 XCAP.EVEN_D_BUF.n11 VSS 1.74907f
C522 XCAP.EVEN_D_BUF.n12 VSS 6.49511f
C523 XCAP.EVEN_D_BUF.t7 VSS 1.37889f
C524 XCAP.EVEN_D_BUF.t6 VSS 0.27794f
C525 XCAP.EVEN_D_BUF.t5 VSS 0.27794f
C526 XCAP.EVEN_D_BUF.n13 VSS 1.05804f
C527 XCAP.EVEN_D_BUF.n14 VSS 0.58157f
C528 XCAP.EVEN_D_BUF.t4 VSS 0.27794f
C529 XCAP.EVEN_D_BUF.t3 VSS 0.27794f
C530 XCAP.EVEN_D_BUF.n15 VSS 1.05804f
C531 XCAP.EVEN_D_BUF.n16 VSS 0.24385f
C532 XCAP.EVEN_D_BUF.t0 VSS 1.37889f
C533 XCAP.EVEN_D_BUF.t2 VSS 0.27794f
C534 XCAP.EVEN_D_BUF.t1 VSS 0.27794f
C535 XCAP.EVEN_D_BUF.n17 VSS 1.05804f
C536 XCAP.EVEN_D_BUF.n18 VSS 0.52182f
C537 XCAP.EVEN_D_BUF.n19 VSS 0.11987f
C538 XCAP.EVEN_D_BUF.t11 VSS 1.37637f
C539 XCAP.EVEN_D_BUF.t10 VSS 0.27794f
C540 XCAP.EVEN_D_BUF.t9 VSS 0.27794f
C541 XCAP.EVEN_D_BUF.n20 VSS 1.05024f
C542 XCAP.EVEN_D_BUF.n21 VSS 0.53215f
C543 XCAP.EVEN_D_BUF.t8 VSS 1.37069f
C544 XCAP.EVEN_D_BUF.n22 VSS 1.1256f
C545 XCAP.EVEN_D_BUF.n23 VSS 2.00092f
C546 XCAP.EVEN_D_BUF.n24 VSS 0.91313f
C547 XCAP.ODD_D_BUF.t11 VSS 1.34525f
C548 XCAP.ODD_D_BUF.t10 VSS 0.27182f
C549 XCAP.ODD_D_BUF.t9 VSS 0.27182f
C550 XCAP.ODD_D_BUF.n0 VSS 1.02634f
C551 XCAP.ODD_D_BUF.n1 VSS 0.52004f
C552 XCAP.ODD_D_BUF.t8 VSS 1.33971f
C553 XCAP.ODD_D_BUF.n2 VSS 1.10721f
C554 XCAP.ODD_D_BUF.t7 VSS 1.34772f
C555 XCAP.ODD_D_BUF.t6 VSS 0.27182f
C556 XCAP.ODD_D_BUF.t5 VSS 0.27182f
C557 XCAP.ODD_D_BUF.n3 VSS 1.03396f
C558 XCAP.ODD_D_BUF.n4 VSS 0.56834f
C559 XCAP.ODD_D_BUF.t4 VSS 0.27182f
C560 XCAP.ODD_D_BUF.t3 VSS 0.27182f
C561 XCAP.ODD_D_BUF.n5 VSS 1.03396f
C562 XCAP.ODD_D_BUF.n6 VSS 0.2383f
C563 XCAP.ODD_D_BUF.t0 VSS 1.34772f
C564 XCAP.ODD_D_BUF.t2 VSS 0.27182f
C565 XCAP.ODD_D_BUF.t1 VSS 0.27182f
C566 XCAP.ODD_D_BUF.n7 VSS 1.03396f
C567 XCAP.ODD_D_BUF.n8 VSS 0.50995f
C568 XCAP.ODD_D_BUF.n9 VSS 0.11678f
C569 XCAP.ODD_D_BUF.n10 VSS 2.49974f
C570 XCAP.ODD_D_BUF.n11 VSS 0.33019f
C571 XCAP.ODD_D_BUF.n12 VSS 0.16321f
C572 XCAP.ODD_D_BUF.n13 VSS 0.17494f
C573 XCAP.ODD_D_BUF.n14 VSS 0.17494f
C574 XCAP.ODD_D_BUF.n15 VSS 0.16534f
C575 XCAP.ODD_D_BUF.n16 VSS 1.68886f
C576 XCAP.ODD_D_BUF.n17 VSS 3.87043f
C577 XCAP.ODD_D_BUF.n18 VSS 0.33019f
C578 XCAP.ODD_D_BUF.n19 VSS 0.16321f
C579 XCAP.ODD_D_BUF.n20 VSS 0.17494f
C580 XCAP.ODD_D_BUF.n21 VSS 0.17494f
C581 XCAP.ODD_D_BUF.n22 VSS 0.16534f
C582 XCAP.ODD_D_BUF.n23 VSS 2.03803f
C583 XCAP.ODD_D_BUF.n24 VSS 3.5691f
C584 XCAP.E_QBI.n0 VSS 0.84803f
C585 XCAP.E_QBI.n1 VSS 0.44045f
C586 XCAP.E_QBI.n2 VSS 3.21925f
C587 XCAP.E_QBI.t7 VSS 1.3223f
C588 XCAP.E_QBI.t6 VSS 1.31385f
C589 XCAP.E_QBI.n3 VSS 1.04291f
C590 XCAP.E_QBI.t9 VSS 1.32006f
C591 XCAP.E_QBI.t8 VSS 1.31159f
C592 XCAP.E_QBI.n4 VSS 0.5077f
C593 XCAP.E_QBI.n5 VSS 1.57463f
C594 XCAP.E_QBI.t10 VSS 1.33522f
C595 XCAP.E_QBI.t11 VSS 0.35565f
C596 XCAP.E_QBI.t2 VSS 0.35565f
C597 XCAP.E_QBI.n6 VSS 0.9346f
C598 XCAP.E_QBI.n7 VSS 0.47356f
C599 XCAP.E_QBI.t3 VSS 1.32683f
C600 XCAP.E_QBI.n8 VSS 0.51261f
C601 XCAP.E_QBI.n9 VSS 0.96021f
C602 XCAP.E_QBI.n10 VSS 1.88012f
C603 XCAP.E_QBI.t0 VSS 1.33746f
C604 XCAP.E_QBI.t1 VSS 0.35565f
C605 XCAP.E_QBI.t4 VSS 0.35565f
C606 XCAP.E_QBI.n11 VSS 0.94155f
C607 XCAP.E_QBI.t5 VSS 1.33412f
C608 XCAP.E_QBI.n12 VSS 2.12356f
C609 XCAP.E_QBI.n13 VSS 0.42173f
C610 XCAP.E_QBI.n14 VSS 3.48843f
C611 XCAP.E_QBI.n15 VSS 0.44926f
C612 XCAP.E_QBI.n16 VSS 1.3761f
C613 XCAP.E_QBI.n17 VSS 0.45859f
C614 XCAP.E_PRST_TAIL.t2 VSS 1.66645f
C615 XCAP.E_PRST_TAIL.t4 VSS 0.31976f
C616 XCAP.E_PRST_TAIL.t3 VSS 0.31976f
C617 XCAP.E_PRST_TAIL.n0 VSS 1.29586f
C618 XCAP.E_PRST_TAIL.n1 VSS 0.71229f
C619 XCAP.E_PRST_TAIL.t6 VSS 0.31976f
C620 XCAP.E_PRST_TAIL.t5 VSS 0.31976f
C621 XCAP.E_PRST_TAIL.n2 VSS 1.29586f
C622 XCAP.E_PRST_TAIL.n3 VSS 0.37183f
C623 XCAP.E_PRST_TAIL.t8 VSS 0.31976f
C624 XCAP.E_PRST_TAIL.t7 VSS 0.31976f
C625 XCAP.E_PRST_TAIL.n4 VSS 1.29586f
C626 XCAP.E_PRST_TAIL.n5 VSS 0.37183f
C627 XCAP.E_PRST_TAIL.t9 VSS 1.65616f
C628 XCAP.E_PRST_TAIL.n6 VSS 5.16751f
C629 XCAP.E_PRST_TAIL.t0 VSS 0.42743f
C630 XCAP.E_PRST_TAIL.t1 VSS 0.4241f
C631 XCAP.E_PRST_TAIL.n7 VSS 1.30601f
C632 XCAP.E_PRST_TAIL.t10 VSS 0.4241f
C633 XCAP.E_PRST_TAIL.t11 VSS 0.4241f
C634 XCAP.E_PRST_TAIL.n8 VSS 1.29586f
C635 XCAP.E_PRST_TAIL.n9 VSS 3.3314f
C636 XCAP.E_PRST_TAIL.n10 VSS 7.14958f
C637 XCAP.O_PRST_TAIL.t2 VSS 0.45317f
C638 XCAP.O_PRST_TAIL.t3 VSS 0.45317f
C639 XCAP.O_PRST_TAIL.n0 VSS 1.47829f
C640 XCAP.O_PRST_TAIL.t0 VSS 0.45317f
C641 XCAP.O_PRST_TAIL.t1 VSS 0.45643f
C642 XCAP.O_PRST_TAIL.n1 VSS 1.4668f
C643 XCAP.O_PRST_TAIL.n2 VSS 3.90634f
C644 XCAP.O_PRST_TAIL.t11 VSS 1.88149f
C645 XCAP.O_PRST_TAIL.t10 VSS 0.35577f
C646 XCAP.O_PRST_TAIL.t9 VSS 0.35577f
C647 XCAP.O_PRST_TAIL.n3 VSS 1.4668f
C648 XCAP.O_PRST_TAIL.n4 VSS 0.80625f
C649 XCAP.O_PRST_TAIL.t8 VSS 0.35577f
C650 XCAP.O_PRST_TAIL.t7 VSS 0.35577f
C651 XCAP.O_PRST_TAIL.n5 VSS 1.4668f
C652 XCAP.O_PRST_TAIL.n6 VSS 0.42088f
C653 XCAP.O_PRST_TAIL.t6 VSS 0.35577f
C654 XCAP.O_PRST_TAIL.t5 VSS 0.35577f
C655 XCAP.O_PRST_TAIL.n7 VSS 1.4668f
C656 XCAP.O_PRST_TAIL.n8 VSS 0.42088f
C657 XCAP.O_PRST_TAIL.t4 VSS 1.86694f
C658 XCAP.O_PRST_TAIL.n9 VSS 3.44009f
C659 XCAP.O_PRST_TAIL.n10 VSS 6.46887f
C660 XCAP.O_QBI.t6 VSS 1.36529f
C661 XCAP.O_QBI.t7 VSS 0.3572f
C662 XCAP.O_QBI.t4 VSS 0.3572f
C663 XCAP.O_QBI.n0 VSS 0.97004f
C664 XCAP.O_QBI.t5 VSS 1.36855f
C665 XCAP.O_QBI.n1 VSS 2.18783f
C666 XCAP.O_QBI.n2 VSS 0.4345f
C667 XCAP.O_QBI.n3 VSS 3.47797f
C668 XCAP.O_QBI.n4 VSS 0.48595f
C669 XCAP.O_QBI.n5 VSS 1.71164f
C670 XCAP.O_QBI.t9 VSS 1.35633f
C671 XCAP.O_QBI.t8 VSS 1.34763f
C672 XCAP.O_QBI.n6 VSS 1.04242f
C673 XCAP.O_QBI.t0 VSS 1.36624f
C674 XCAP.O_QBI.t1 VSS 0.3572f
C675 XCAP.O_QBI.t2 VSS 0.3572f
C676 XCAP.O_QBI.n7 VSS 0.96289f
C677 XCAP.O_QBI.n8 VSS 0.48789f
C678 XCAP.O_QBI.t3 VSS 1.35778f
C679 XCAP.O_QBI.n9 VSS 0.57498f
C680 XCAP.O_QBI.t11 VSS 1.35402f
C681 XCAP.O_QBI.t10 VSS 1.3453f
C682 XCAP.O_QBI.n10 VSS 0.52306f
C683 XCAP.O_QBI.n11 VSS 1.05845f
C684 XCAP.O_QBI.n12 VSS 1.53829f
C685 XCAP.O_QBI.n13 VSS 1.50493f
C686 XCAP.O_QBI.n14 VSS 0.8737f
C687 XCAP.O_QBI.n15 VSS 0.45378f
C688 XCAP.O_QBI.n16 VSS 2.72459f
C689 XCAP.O_QBI.n17 VSS 0.66575f
C690 XCAP.E_QBBUF.t1 VSS 1.15841f
C691 XCAP.E_QBBUF.t0 VSS 1.15119f
C692 XCAP.E_QBBUF.n0 VSS 1.11868f
C693 XCAP.E_QBBUF.t3 VSS 0.55612f
C694 XCAP.E_QBBUF.t2 VSS 0.54975f
C695 XCAP.E_QBBUF.n1 VSS 0.49446f
C696 XCAP.E_QBBUF.n2 VSS 2.10122f
C697 XCAP.E_QBBUF.n3 VSS 0.12582f
C698 XCAP.E_QBBUF.n4 VSS 0.13681f
C699 XCAP.E_QBBUF.n5 VSS 0.13681f
C700 XCAP.E_QBBUF.n6 VSS 0.12582f
C701 XCAP.E_QBBUF.n7 VSS 1.1405f
C702 XCAP.E_QBBUF.n8 VSS 0.12979f
C703 XCAP.E_QBBUF.n9 VSS 0.13681f
C704 XCAP.E_QBBUF.n10 VSS 0.1247f
C705 XCAP.E_QBBUF.n11 VSS 0.29031f
C706 XCAP.E_QBBUF.n12 VSS 2.47221f
C707 XCAP.E_QBBUF.n13 VSS 0.71331f
C708 XCAP.E_QBUF.t2 VSS 1.10555f
C709 XCAP.E_QBUF.t0 VSS 1.09867f
C710 XCAP.E_QBUF.n0 VSS 1.06423f
C711 XCAP.E_QBUF.t1 VSS 0.53094f
C712 XCAP.E_QBUF.t3 VSS 0.52489f
C713 XCAP.E_QBUF.n1 VSS 0.47039f
C714 XCAP.E_QBUF.n2 VSS 1.92533f
C715 XCAP.E_QBUF.n3 VSS 0.11969f
C716 XCAP.E_QBUF.n4 VSS 0.13015f
C717 XCAP.E_QBUF.n5 VSS 0.13015f
C718 XCAP.E_QBUF.n6 VSS 0.11969f
C719 XCAP.E_QBUF.n7 VSS 1.08499f
C720 XCAP.E_QBUF.n8 VSS 0.12347f
C721 XCAP.E_QBUF.n9 VSS 0.13015f
C722 XCAP.E_QBUF.n10 VSS 0.11863f
C723 XCAP.E_QBUF.n11 VSS 0.27618f
C724 XCAP.E_QBUF.n12 VSS 2.26498f
C725 XCAP.E_QBUF.n13 VSS 0.65507f
C726 XCAP.O_QBUF.n0 VSS 0.12253f
C727 XCAP.O_QBUF.n1 VSS 0.13323f
C728 XCAP.O_QBUF.n2 VSS 0.13323f
C729 XCAP.O_QBUF.n3 VSS 0.12253f
C730 XCAP.O_QBUF.n4 VSS 1.04857f
C731 XCAP.O_QBUF.n5 VSS 0.12639f
C732 XCAP.O_QBUF.n6 VSS 0.13323f
C733 XCAP.O_QBUF.n7 VSS 0.12143f
C734 XCAP.O_QBUF.n8 VSS 0.28917f
C735 XCAP.O_QBUF.n9 VSS 2.53404f
C736 XCAP.O_QBUF.t1 VSS 1.13276f
C737 XCAP.O_QBUF.t3 VSS 1.12572f
C738 XCAP.O_QBUF.n10 VSS 1.08943f
C739 XCAP.O_QBUF.t2 VSS 0.54407f
C740 XCAP.O_QBUF.t0 VSS 0.53788f
C741 XCAP.O_QBUF.n11 VSS 0.48153f
C742 XCAP.O_QBUF.n12 VSS 1.70254f
C743 XCAP.O_QBUF.n13 VSS 0.78588f
C744 XCAP.O_QBBUF.n0 VSS 0.13089f
C745 XCAP.O_QBBUF.n1 VSS 0.14232f
C746 XCAP.O_QBBUF.n2 VSS 0.14232f
C747 XCAP.O_QBBUF.n3 VSS 0.13089f
C748 XCAP.O_QBBUF.n4 VSS 1.1571f
C749 XCAP.O_QBBUF.n5 VSS 0.13501f
C750 XCAP.O_QBBUF.n6 VSS 0.14232f
C751 XCAP.O_QBBUF.n7 VSS 0.12972f
C752 XCAP.O_QBBUF.n8 VSS 0.30396f
C753 XCAP.O_QBBUF.n9 VSS 2.67488f
C754 XCAP.O_QBBUF.t1 VSS 1.19746f
C755 XCAP.O_QBBUF.t0 VSS 1.18994f
C756 XCAP.O_QBBUF.n10 VSS 1.16376f
C757 XCAP.O_QBBUF.t3 VSS 0.57442f
C758 XCAP.O_QBBUF.t2 VSS 0.5678f
C759 XCAP.O_QBBUF.n11 VSS 0.51438f
C760 XCAP.O_QBBUF.n12 VSS 1.90408f
C761 XCAP.O_QBBUF.n13 VSS 0.85474f
C762 XCAP.E_QI.n0 VSS 0.63088f
C763 XCAP.E_QI.n1 VSS 0.45242f
C764 XCAP.E_QI.n2 VSS 2.36456f
C765 XCAP.E_QI.t6 VSS 1.34407f
C766 XCAP.E_QI.t5 VSS 0.33566f
C767 XCAP.E_QI.t4 VSS 0.33566f
C768 XCAP.E_QI.n3 VSS 0.96761f
C769 XCAP.E_QI.n4 VSS 0.47722f
C770 XCAP.E_QI.t3 VSS 1.33603f
C771 XCAP.E_QI.n5 VSS 0.57123f
C772 XCAP.E_QI.t11 VSS 1.35007f
C773 XCAP.E_QI.t2 VSS 1.34138f
C774 XCAP.E_QI.n6 VSS 0.51712f
C775 XCAP.E_QI.n7 VSS 2.04798f
C776 XCAP.E_QI.t1 VSS 1.34776f
C777 XCAP.E_QI.t0 VSS 1.33906f
C778 XCAP.E_QI.n8 VSS 0.52175f
C779 XCAP.E_QI.n9 VSS 1.16581f
C780 XCAP.E_QI.t10 VSS 1.34176f
C781 XCAP.E_QI.t9 VSS 0.33566f
C782 XCAP.E_QI.t8 VSS 0.33566f
C783 XCAP.E_QI.n10 VSS 0.96048f
C784 XCAP.E_QI.n11 VSS 0.48667f
C785 XCAP.E_QI.t7 VSS 1.33372f
C786 XCAP.E_QI.n12 VSS 0.8327f
C787 XCAP.E_QI.n13 VSS 1.61519f
C788 XCAP.E_QI.n14 VSS 1.78228f
C789 XCAP.E_QI.n15 VSS 0.81587f
C790 XCAP.E_QI.n16 VSS 0.40427f
C791 XCAP.E_QI.n17 VSS 2.92071f
C792 XCAP.E_QI.n18 VSS 1.02098f
C793 XCAP.EVEN_DB_BUF.n0 VSS 0.2892f
C794 XCAP.EVEN_DB_BUF.n1 VSS 0.14295f
C795 XCAP.EVEN_DB_BUF.n2 VSS 0.15323f
C796 XCAP.EVEN_DB_BUF.n3 VSS 0.15323f
C797 XCAP.EVEN_DB_BUF.n4 VSS 0.14482f
C798 XCAP.EVEN_DB_BUF.n5 VSS 0.28527f
C799 XCAP.EVEN_DB_BUF.n6 VSS 0.2892f
C800 XCAP.EVEN_DB_BUF.n7 VSS 0.14295f
C801 XCAP.EVEN_DB_BUF.n8 VSS 0.15323f
C802 XCAP.EVEN_DB_BUF.n9 VSS 0.15323f
C803 XCAP.EVEN_DB_BUF.n10 VSS 0.14482f
C804 XCAP.EVEN_DB_BUF.n11 VSS 1.62031f
C805 XCAP.EVEN_DB_BUF.n12 VSS 4.02148f
C806 XCAP.EVEN_DB_BUF.t11 VSS 1.18827f
C807 XCAP.EVEN_DB_BUF.t10 VSS 0.2479f
C808 XCAP.EVEN_DB_BUF.t9 VSS 0.2479f
C809 XCAP.EVEN_DB_BUF.n13 VSS 0.89894f
C810 XCAP.EVEN_DB_BUF.n14 VSS 0.45549f
C811 XCAP.EVEN_DB_BUF.t8 VSS 1.18342f
C812 XCAP.EVEN_DB_BUF.n15 VSS 0.96977f
C813 XCAP.EVEN_DB_BUF.t7 VSS 1.19043f
C814 XCAP.EVEN_DB_BUF.t6 VSS 0.2479f
C815 XCAP.EVEN_DB_BUF.t5 VSS 0.2479f
C816 XCAP.EVEN_DB_BUF.n16 VSS 0.90562f
C817 XCAP.EVEN_DB_BUF.n17 VSS 0.49779f
C818 XCAP.EVEN_DB_BUF.t4 VSS 0.2479f
C819 XCAP.EVEN_DB_BUF.t3 VSS 0.2479f
C820 XCAP.EVEN_DB_BUF.n18 VSS 0.90562f
C821 XCAP.EVEN_DB_BUF.n19 VSS 0.20872f
C822 XCAP.EVEN_DB_BUF.t0 VSS 1.19043f
C823 XCAP.EVEN_DB_BUF.t2 VSS 0.2479f
C824 XCAP.EVEN_DB_BUF.t1 VSS 0.2479f
C825 XCAP.EVEN_DB_BUF.n20 VSS 0.90562f
C826 XCAP.EVEN_DB_BUF.n21 VSS 0.44665f
C827 XCAP.EVEN_DB_BUF.n22 VSS 0.10228f
C828 XCAP.EVEN_DB_BUF.n23 VSS 1.79576f
C829 XCAP.EVEN_DB_BUF.n24 VSS 0.71125f
C830 XCAP.ODD_DB_BUF.t11 VSS 1.19917f
C831 XCAP.ODD_DB_BUF.t10 VSS 0.2446f
C832 XCAP.ODD_DB_BUF.t9 VSS 0.2446f
C833 XCAP.ODD_DB_BUF.n0 VSS 0.91264f
C834 XCAP.ODD_DB_BUF.n1 VSS 0.46243f
C835 XCAP.ODD_DB_BUF.t8 VSS 1.19424f
C836 XCAP.ODD_DB_BUF.n2 VSS 0.98455f
C837 XCAP.ODD_DB_BUF.t7 VSS 1.20136f
C838 XCAP.ODD_DB_BUF.t6 VSS 0.2446f
C839 XCAP.ODD_DB_BUF.t5 VSS 0.2446f
C840 XCAP.ODD_DB_BUF.n3 VSS 0.91942f
C841 XCAP.ODD_DB_BUF.n4 VSS 0.50537f
C842 XCAP.ODD_DB_BUF.t4 VSS 0.2446f
C843 XCAP.ODD_DB_BUF.t3 VSS 0.2446f
C844 XCAP.ODD_DB_BUF.n5 VSS 0.91942f
C845 XCAP.ODD_DB_BUF.n6 VSS 0.2119f
C846 XCAP.ODD_DB_BUF.t0 VSS 1.20136f
C847 XCAP.ODD_DB_BUF.t2 VSS 0.2446f
C848 XCAP.ODD_DB_BUF.t1 VSS 0.2446f
C849 XCAP.ODD_DB_BUF.n7 VSS 0.91942f
C850 XCAP.ODD_DB_BUF.n8 VSS 0.45345f
C851 XCAP.ODD_DB_BUF.n9 VSS 0.10384f
C852 XCAP.ODD_DB_BUF.n10 VSS 2.21745f
C853 XCAP.ODD_DB_BUF.n11 VSS 0.29361f
C854 XCAP.ODD_DB_BUF.n12 VSS 0.14513f
C855 XCAP.ODD_DB_BUF.n13 VSS 0.15556f
C856 XCAP.ODD_DB_BUF.n14 VSS 0.15556f
C857 XCAP.ODD_DB_BUF.n15 VSS 0.14702f
C858 XCAP.ODD_DB_BUF.n16 VSS 0.26874f
C859 XCAP.ODD_DB_BUF.n17 VSS 0.29361f
C860 XCAP.ODD_DB_BUF.n18 VSS 0.14513f
C861 XCAP.ODD_DB_BUF.n19 VSS 0.15556f
C862 XCAP.ODD_DB_BUF.n20 VSS 0.15556f
C863 XCAP.ODD_DB_BUF.n21 VSS 0.14702f
C864 XCAP.ODD_DB_BUF.n22 VSS 1.73534f
C865 XCAP.ODD_DB_BUF.n23 VSS 3.87678f
C866 XCAP.ODD_DB_BUF.n24 VSS 0.93564f
C867 XCAP.O_QI.n0 VSS 0.81035f
C868 XCAP.O_QI.n1 VSS 0.40154f
C869 XCAP.O_QI.n2 VSS 3.28197f
C870 XCAP.O_QI.t3 VSS 1.33831f
C871 XCAP.O_QI.t4 VSS 0.33666f
C872 XCAP.O_QI.t5 VSS 0.33666f
C873 XCAP.O_QI.n3 VSS 0.96107f
C874 XCAP.O_QI.n4 VSS 0.474f
C875 XCAP.O_QI.t6 VSS 1.33027f
C876 XCAP.O_QI.n5 VSS 0.56737f
C877 XCAP.O_QI.t0 VSS 1.34677f
C878 XCAP.O_QI.t1 VSS 1.33815f
C879 XCAP.O_QI.n6 VSS 0.51362f
C880 XCAP.O_QI.n7 VSS 2.03413f
C881 XCAP.O_QI.t2 VSS 1.34448f
C882 XCAP.O_QI.t7 VSS 1.33584f
C883 XCAP.O_QI.n8 VSS 0.51822f
C884 XCAP.O_QI.n9 VSS 1.04296f
C885 XCAP.O_QI.t8 VSS 1.33602f
C886 XCAP.O_QI.t9 VSS 0.33666f
C887 XCAP.O_QI.t10 VSS 0.33666f
C888 XCAP.O_QI.n10 VSS 0.95398f
C889 XCAP.O_QI.n11 VSS 0.48338f
C890 XCAP.O_QI.t11 VSS 1.32798f
C891 XCAP.O_QI.n12 VSS 0.9167f
C892 XCAP.O_QI.n13 VSS 1.6296f
C893 XCAP.O_QI.n14 VSS 2.1671f
C894 XCAP.O_QI.n15 VSS 0.58411f
C895 XCAP.O_QI.n16 VSS 0.46929f
C896 XCAP.O_QI.n17 VSS 2.17206f
C897 XCAP.O_QI.n18 VSS 0.4681f
C898 XCAP.E_PSET_TAIL.t7 VSS 1.97714f
C899 XCAP.E_PSET_TAIL.t6 VSS 0.36826f
C900 XCAP.E_PSET_TAIL.t5 VSS 0.36826f
C901 XCAP.E_PSET_TAIL.n0 VSS 1.54688f
C902 XCAP.E_PSET_TAIL.n1 VSS 0.85027f
C903 XCAP.E_PSET_TAIL.t4 VSS 0.36826f
C904 XCAP.E_PSET_TAIL.t3 VSS 0.36826f
C905 XCAP.E_PSET_TAIL.n2 VSS 1.54688f
C906 XCAP.E_PSET_TAIL.n3 VSS 0.44386f
C907 XCAP.E_PSET_TAIL.t2 VSS 0.36826f
C908 XCAP.E_PSET_TAIL.t1 VSS 0.36826f
C909 XCAP.E_PSET_TAIL.n4 VSS 1.54688f
C910 XCAP.E_PSET_TAIL.n5 VSS 0.44386f
C911 XCAP.E_PSET_TAIL.t0 VSS 1.96193f
C912 XCAP.E_PSET_TAIL.n6 VSS 2.2193f
C913 XCAP.E_PSET_TAIL.t9 VSS 0.45042f
C914 XCAP.E_PSET_TAIL.t10 VSS 0.44756f
C915 XCAP.E_PSET_TAIL.n7 VSS 1.55899f
C916 XCAP.E_PSET_TAIL.t11 VSS 0.44756f
C917 XCAP.E_PSET_TAIL.t8 VSS 0.44756f
C918 XCAP.E_PSET_TAIL.n8 VSS 1.54688f
C919 XCAP.E_PSET_TAIL.n9 VSS 2.2126f
C920 XCAP.E_PSET_TAIL.n10 VSS 3.81367f
C921 XCAP.O_PSET_TAIL.t2 VSS 0.43217f
C922 XCAP.O_PSET_TAIL.t3 VSS 0.43217f
C923 XCAP.O_PSET_TAIL.n0 VSS 1.46688f
C924 XCAP.O_PSET_TAIL.t0 VSS 0.43507f
C925 XCAP.O_PSET_TAIL.t1 VSS 0.43217f
C926 XCAP.O_PSET_TAIL.n1 VSS 1.45549f
C927 XCAP.O_PSET_TAIL.n2 VSS 2.74646f
C928 XCAP.O_PSET_TAIL.t11 VSS 1.86755f
C929 XCAP.O_PSET_TAIL.t10 VSS 0.35358f
C930 XCAP.O_PSET_TAIL.t9 VSS 0.35358f
C931 XCAP.O_PSET_TAIL.n3 VSS 1.45549f
C932 XCAP.O_PSET_TAIL.n4 VSS 0.80004f
C933 XCAP.O_PSET_TAIL.t8 VSS 0.35358f
C934 XCAP.O_PSET_TAIL.t7 VSS 0.35358f
C935 XCAP.O_PSET_TAIL.n5 VSS 1.45549f
C936 XCAP.O_PSET_TAIL.n6 VSS 0.41764f
C937 XCAP.O_PSET_TAIL.t6 VSS 0.35358f
C938 XCAP.O_PSET_TAIL.t5 VSS 0.35358f
C939 XCAP.O_PSET_TAIL.n7 VSS 1.45549f
C940 XCAP.O_PSET_TAIL.n8 VSS 0.41764f
C941 XCAP.O_PSET_TAIL.t4 VSS 1.8531f
C942 XCAP.O_PSET_TAIL.n9 VSS 1.58693f
C943 XCAP.O_PSET_TAIL.n10 VSS 4.05229f
C944 XCAP.E_SET_TAIL.t0 VSS 0.3085f
C945 XCAP.E_SET_TAIL.t1 VSS 0.3085f
C946 XCAP.E_SET_TAIL.n0 VSS 0.69793f
C947 XCAP.E_SET_TAIL.t10 VSS 0.31184f
C948 XCAP.E_SET_TAIL.t11 VSS 0.3085f
C949 XCAP.E_SET_TAIL.n1 VSS 0.69236f
C950 XCAP.E_SET_TAIL.n2 VSS 0.55269f
C951 XCAP.E_SET_TAIL.t9 VSS 0.89666f
C952 XCAP.E_SET_TAIL.t8 VSS 0.17274f
C953 XCAP.E_SET_TAIL.t7 VSS 0.17274f
C954 XCAP.E_SET_TAIL.n3 VSS 0.69236f
C955 XCAP.E_SET_TAIL.n4 VSS 0.3902f
C956 XCAP.E_SET_TAIL.t6 VSS 0.17274f
C957 XCAP.E_SET_TAIL.t5 VSS 0.17274f
C958 XCAP.E_SET_TAIL.n5 VSS 0.69236f
C959 XCAP.E_SET_TAIL.n6 VSS 0.20528f
C960 XCAP.E_SET_TAIL.t2 VSS 0.89666f
C961 XCAP.E_SET_TAIL.t4 VSS 0.17274f
C962 XCAP.E_SET_TAIL.t3 VSS 0.17274f
C963 XCAP.E_SET_TAIL.n7 VSS 0.69236f
C964 XCAP.E_SET_TAIL.n8 VSS 0.59761f
C965 XCAP.E_SET_TAIL.n9 VSS 1.04754f
C966 XCAP.O_SET_TAIL.t11 VSS 0.87379f
C967 XCAP.O_SET_TAIL.t10 VSS 0.17065f
C968 XCAP.O_SET_TAIL.t9 VSS 0.17065f
C969 XCAP.O_SET_TAIL.n0 VSS 0.67242f
C970 XCAP.O_SET_TAIL.n1 VSS 0.37897f
C971 XCAP.O_SET_TAIL.t8 VSS 0.17065f
C972 XCAP.O_SET_TAIL.t7 VSS 0.17065f
C973 XCAP.O_SET_TAIL.n2 VSS 0.67242f
C974 XCAP.O_SET_TAIL.n3 VSS 0.19937f
C975 XCAP.O_SET_TAIL.t4 VSS 0.87379f
C976 XCAP.O_SET_TAIL.t6 VSS 0.17065f
C977 XCAP.O_SET_TAIL.t5 VSS 0.17065f
C978 XCAP.O_SET_TAIL.n4 VSS 0.67242f
C979 XCAP.O_SET_TAIL.n5 VSS 0.55941f
C980 XCAP.O_SET_TAIL.t2 VSS 0.30067f
C981 XCAP.O_SET_TAIL.t3 VSS 0.30067f
C982 XCAP.O_SET_TAIL.n6 VSS 0.67784f
C983 XCAP.O_SET_TAIL.t0 VSS 0.30393f
C984 XCAP.O_SET_TAIL.t1 VSS 0.30067f
C985 XCAP.O_SET_TAIL.n7 VSS 0.67242f
C986 XCAP.O_SET_TAIL.n8 VSS 0.49654f
C987 XCAP.O_SET_TAIL.n9 VSS 0.70815f
C988 XCAP.E_RST_TAIL.t7 VSS 0.69824f
C989 XCAP.E_RST_TAIL.t6 VSS 0.14169f
C990 XCAP.E_RST_TAIL.t5 VSS 0.14169f
C991 XCAP.E_RST_TAIL.n0 VSS 0.53282f
C992 XCAP.E_RST_TAIL.n1 VSS 0.30029f
C993 XCAP.E_RST_TAIL.t4 VSS 0.14169f
C994 XCAP.E_RST_TAIL.t3 VSS 0.14169f
C995 XCAP.E_RST_TAIL.n2 VSS 0.53282f
C996 XCAP.E_RST_TAIL.n3 VSS 0.15798f
C997 XCAP.E_RST_TAIL.t2 VSS 0.14169f
C998 XCAP.E_RST_TAIL.t1 VSS 0.14169f
C999 XCAP.E_RST_TAIL.n4 VSS 0.53282f
C1000 XCAP.E_RST_TAIL.n5 VSS 0.12767f
C1001 XCAP.E_RST_TAIL.t0 VSS 0.6961f
C1002 XCAP.E_RST_TAIL.n6 VSS 0.39529f
C1003 XCAP.E_RST_TAIL.t10 VSS 0.25242f
C1004 XCAP.E_RST_TAIL.t11 VSS 0.25242f
C1005 XCAP.E_RST_TAIL.n7 VSS 0.53711f
C1006 XCAP.E_RST_TAIL.t8 VSS 0.25528f
C1007 XCAP.E_RST_TAIL.t9 VSS 0.25242f
C1008 XCAP.E_RST_TAIL.n8 VSS 0.53282f
C1009 XCAP.E_RST_TAIL.n9 VSS 0.74854f
C1010 XCAP.E_RST_TAIL.n10 VSS 0.8009f
C1011 XCAP.O_RST_TAIL.t10 VSS 0.26572f
C1012 XCAP.O_RST_TAIL.t11 VSS 0.26572f
C1013 XCAP.O_RST_TAIL.n0 VSS 0.59423f
C1014 XCAP.O_RST_TAIL.t8 VSS 0.26861f
C1015 XCAP.O_RST_TAIL.t9 VSS 0.26572f
C1016 XCAP.O_RST_TAIL.n1 VSS 0.58949f
C1017 XCAP.O_RST_TAIL.n2 VSS 1.09562f
C1018 XCAP.O_RST_TAIL.t7 VSS 0.77026f
C1019 XCAP.O_RST_TAIL.t6 VSS 0.15451f
C1020 XCAP.O_RST_TAIL.t5 VSS 0.15451f
C1021 XCAP.O_RST_TAIL.n3 VSS 0.58949f
C1022 XCAP.O_RST_TAIL.n4 VSS 0.33223f
C1023 XCAP.O_RST_TAIL.t4 VSS 0.15451f
C1024 XCAP.O_RST_TAIL.t3 VSS 0.15451f
C1025 XCAP.O_RST_TAIL.n5 VSS 0.58949f
C1026 XCAP.O_RST_TAIL.n6 VSS 0.17478f
C1027 XCAP.O_RST_TAIL.t2 VSS 0.15451f
C1028 XCAP.O_RST_TAIL.t1 VSS 0.15451f
C1029 XCAP.O_RST_TAIL.n7 VSS 0.58949f
C1030 XCAP.O_RST_TAIL.n8 VSS 0.14125f
C1031 XCAP.O_RST_TAIL.t0 VSS 0.76784f
C1032 XCAP.O_RST_TAIL.n9 VSS 0.46717f
C1033 XCAP.O_RST_TAIL.n10 VSS 1.44128f
C1034 XFRONT.XFE_E.VREGN.t7 VSS 2.05441f
C1035 XFRONT.XFE_E.VREGN.t6 VSS 0.43778f
C1036 XFRONT.XFE_E.VREGN.t5 VSS 0.43778f
C1037 XFRONT.XFE_E.VREGN.n0 VSS 1.55201f
C1038 XFRONT.XFE_E.VREGN.n1 VSS 0.85309f
C1039 XFRONT.XFE_E.VREGN.t4 VSS 0.43778f
C1040 XFRONT.XFE_E.VREGN.t3 VSS 0.43778f
C1041 XFRONT.XFE_E.VREGN.n2 VSS 1.55201f
C1042 XFRONT.XFE_E.VREGN.n3 VSS 0.35769f
C1043 XFRONT.XFE_E.VREGN.t0 VSS 2.05072f
C1044 XFRONT.XFE_E.VREGN.t2 VSS 0.43778f
C1045 XFRONT.XFE_E.VREGN.t1 VSS 0.43778f
C1046 XFRONT.XFE_E.VREGN.n4 VSS 1.55201f
C1047 XFRONT.XFE_E.VREGN.n5 VSS 0.76545f
C1048 XFRONT.XFE_E.VREGN.n6 VSS 0.70781f
C1049 XFRONT.XFE_E.VREGN.t15 VSS 0.44748f
C1050 XFRONT.XFE_E.VREGN.t14 VSS 0.44357f
C1051 XFRONT.XFE_E.VREGN.n7 VSS 1.56416f
C1052 XFRONT.XFE_E.VREGN.t13 VSS 0.44357f
C1053 XFRONT.XFE_E.VREGN.t12 VSS 0.44357f
C1054 XFRONT.XFE_E.VREGN.n8 VSS 1.55201f
C1055 XFRONT.XFE_E.VREGN.n9 VSS 0.78649f
C1056 XFRONT.XFE_E.VREGN.t11 VSS 0.44357f
C1057 XFRONT.XFE_E.VREGN.t10 VSS 0.44357f
C1058 XFRONT.XFE_E.VREGN.n10 VSS 1.55201f
C1059 XFRONT.XFE_E.VREGN.n11 VSS 0.44533f
C1060 XFRONT.XFE_E.VREGN.t9 VSS 0.44357f
C1061 XFRONT.XFE_E.VREGN.t8 VSS 0.44357f
C1062 XFRONT.XFE_E.VREGN.n12 VSS 1.55201f
C1063 XFRONT.XFE_E.VREGN.n13 VSS 1.47521f
C1064 XFRONT.XFE_E.VREGN.n14 VSS 1.97789f
C1065 XFRONT.XFE_E.SB.n0 VSS 0.13155f
C1066 XFRONT.XFE_E.SB.n1 VSS 0.08021f
C1067 XFRONT.XFE_E.SB.n2 VSS 0.2771f
C1068 XFRONT.XFE_E.SB.n3 VSS 0.14681f
C1069 XFRONT.XFE_E.SB.n4 VSS 0.2771f
C1070 XFRONT.XFE_E.SB.n5 VSS 0.13697f
C1071 XFRONT.XFE_E.SB.n6 VSS 0.14681f
C1072 XFRONT.XFE_E.SB.n7 VSS 0.40649f
C1073 XFRONT.XFE_E.SB.n8 VSS 0.20576f
C1074 XFRONT.XFE_E.SB.n9 VSS 0.19077f
C1075 XFRONT.XFE_E.SB.n10 VSS 0.14681f
C1076 XFRONT.XFE_E.SB.n11 VSS 0.14681f
C1077 XFRONT.XFE_E.SB.n12 VSS 0.19077f
C1078 XFRONT.XFE_E.SB.n13 VSS 0.13697f
C1079 XFRONT.XFE_E.SB.n14 VSS 0.40649f
C1080 XFRONT.XFE_E.SB.n15 VSS 0.20576f
C1081 XFRONT.XFE_E.SB.n16 VSS 0.14681f
C1082 XFRONT.XFE_E.SB.n17 VSS 0.14681f
C1083 XFRONT.XFE_E.SB.n18 VSS 0.08021f
C1084 XFRONT.XFE_E.SB.n19 VSS 0.06663f
C1085 XFRONT.XFE_E.SB.n20 VSS 0.97831f
C1086 XFRONT.XFE_E.SB.t2 VSS 1.23317f
C1087 XFRONT.XFE_E.SB.t1 VSS 1.22543f
C1088 XFRONT.XFE_E.SB.n21 VSS 1.08915f
C1089 XFRONT.XFE_E.SB.t6 VSS 1.12965f
C1090 XFRONT.XFE_E.SB.t5 VSS 1.13745f
C1091 XFRONT.XFE_E.SB.n22 VSS 0.46789f
C1092 XFRONT.XFE_E.SB.n23 VSS 1.54724f
C1093 XFRONT.XFE_E.SB.t0 VSS 2.07955f
C1094 XFRONT.XFE_E.SB.t4 VSS 0.33146f
C1095 XFRONT.XFE_E.SB.t3 VSS 0.33143f
C1096 XFRONT.XFE_E.SB.n24 VSS 1.07064f
C1097 XFRONT.XFE_E.SB.n25 VSS 2.8859f
C1098 XFRONT.XFE_E.SB.n26 VSS 2.7955f
C1099 XFRONT.XFE_E.SA.t1 VSS 1.28668f
C1100 XFRONT.XFE_E.SA.t2 VSS 1.27847f
C1101 XFRONT.XFE_E.SA.n0 VSS 1.33857f
C1102 XFRONT.XFE_E.SA.t6 VSS 1.16514f
C1103 XFRONT.XFE_E.SA.t5 VSS 1.17333f
C1104 XFRONT.XFE_E.SA.n1 VSS 0.49128f
C1105 XFRONT.XFE_E.SA.n2 VSS 1.53905f
C1106 XFRONT.XFE_E.SA.n3 VSS 0.13813f
C1107 XFRONT.XFE_E.SA.n4 VSS 0.08422f
C1108 XFRONT.XFE_E.SA.n5 VSS 0.29096f
C1109 XFRONT.XFE_E.SA.n6 VSS 0.15416f
C1110 XFRONT.XFE_E.SA.n7 VSS 0.29096f
C1111 XFRONT.XFE_E.SA.n8 VSS 0.14381f
C1112 XFRONT.XFE_E.SA.n9 VSS 0.15416f
C1113 XFRONT.XFE_E.SA.n10 VSS 0.42682f
C1114 XFRONT.XFE_E.SA.n11 VSS 0.21605f
C1115 XFRONT.XFE_E.SA.n12 VSS 0.20031f
C1116 XFRONT.XFE_E.SA.n13 VSS 0.15416f
C1117 XFRONT.XFE_E.SA.n14 VSS 0.15416f
C1118 XFRONT.XFE_E.SA.n15 VSS 0.20031f
C1119 XFRONT.XFE_E.SA.n16 VSS 0.14381f
C1120 XFRONT.XFE_E.SA.n17 VSS 0.42682f
C1121 XFRONT.XFE_E.SA.n18 VSS 0.21605f
C1122 XFRONT.XFE_E.SA.n19 VSS 0.15416f
C1123 XFRONT.XFE_E.SA.n20 VSS 0.15416f
C1124 XFRONT.XFE_E.SA.n21 VSS 0.08422f
C1125 XFRONT.XFE_E.SA.n22 VSS 0.06997f
C1126 XFRONT.XFE_E.SA.n23 VSS 1.7301f
C1127 XFRONT.XFE_E.SA.t0 VSS 2.0847f
C1128 XFRONT.XFE_E.SA.t3 VSS 1.28664f
C1129 XFRONT.XFE_E.SA.t4 VSS 1.27851f
C1130 XFRONT.XFE_E.SA.n24 VSS 0.7353f
C1131 XFRONT.XFE_E.SA.n25 VSS 2.83246f
C1132 XFRONT.XFE_E.SA.n26 VSS 3.35641f
C1133 XFRONT.XFE_E.VREGP.t9 VSS 0.46595f
C1134 XFRONT.XFE_E.VREGP.t8 VSS 0.46998f
C1135 XFRONT.XFE_E.VREGP.n0 VSS 1.65721f
C1136 XFRONT.XFE_E.VREGP.t11 VSS 0.46595f
C1137 XFRONT.XFE_E.VREGP.t10 VSS 0.46595f
C1138 XFRONT.XFE_E.VREGP.n1 VSS 1.64434f
C1139 XFRONT.XFE_E.VREGP.n2 VSS 0.83328f
C1140 XFRONT.XFE_E.VREGP.t13 VSS 0.46595f
C1141 XFRONT.XFE_E.VREGP.t12 VSS 0.46595f
C1142 XFRONT.XFE_E.VREGP.n3 VSS 1.64434f
C1143 XFRONT.XFE_E.VREGP.n4 VSS 0.47183f
C1144 XFRONT.XFE_E.VREGP.t15 VSS 0.46998f
C1145 XFRONT.XFE_E.VREGP.t14 VSS 0.46595f
C1146 XFRONT.XFE_E.VREGP.n5 VSS 1.64434f
C1147 XFRONT.XFE_E.VREGP.n6 VSS 2.2363f
C1148 XFRONT.XFE_E.VREGP.t7 VSS 2.1682f
C1149 XFRONT.XFE_E.VREGP.t6 VSS 0.45561f
C1150 XFRONT.XFE_E.VREGP.t5 VSS 0.45561f
C1151 XFRONT.XFE_E.VREGP.n7 VSS 1.64434f
C1152 XFRONT.XFE_E.VREGP.n8 VSS 0.81098f
C1153 XFRONT.XFE_E.VREGP.t0 VSS 2.1682f
C1154 XFRONT.XFE_E.VREGP.t2 VSS 0.45561f
C1155 XFRONT.XFE_E.VREGP.t1 VSS 0.45561f
C1156 XFRONT.XFE_E.VREGP.n9 VSS 1.64434f
C1157 XFRONT.XFE_E.VREGP.n10 VSS 0.90384f
C1158 XFRONT.XFE_E.VREGP.t4 VSS 0.45561f
C1159 XFRONT.XFE_E.VREGP.t3 VSS 0.45561f
C1160 XFRONT.XFE_E.VREGP.n11 VSS 1.64434f
C1161 XFRONT.XFE_E.VREGP.n12 VSS 0.37897f
C1162 XFRONT.XFE_E.VREGP.n13 VSS 1.21829f
C1163 XFRONT.XFE_O.VREGP.t7 VSS 2.1682f
C1164 XFRONT.XFE_O.VREGP.t6 VSS 0.45561f
C1165 XFRONT.XFE_O.VREGP.t5 VSS 0.45561f
C1166 XFRONT.XFE_O.VREGP.n0 VSS 1.64434f
C1167 XFRONT.XFE_O.VREGP.n1 VSS 0.90384f
C1168 XFRONT.XFE_O.VREGP.t4 VSS 0.45561f
C1169 XFRONT.XFE_O.VREGP.t3 VSS 0.45561f
C1170 XFRONT.XFE_O.VREGP.n2 VSS 1.64434f
C1171 XFRONT.XFE_O.VREGP.n3 VSS 0.37897f
C1172 XFRONT.XFE_O.VREGP.t0 VSS 2.1682f
C1173 XFRONT.XFE_O.VREGP.t2 VSS 0.45561f
C1174 XFRONT.XFE_O.VREGP.t1 VSS 0.45561f
C1175 XFRONT.XFE_O.VREGP.n4 VSS 1.64434f
C1176 XFRONT.XFE_O.VREGP.n5 VSS 0.81098f
C1177 XFRONT.XFE_O.VREGP.n6 VSS 1.22138f
C1178 XFRONT.XFE_O.VREGP.t15 VSS 0.46998f
C1179 XFRONT.XFE_O.VREGP.t14 VSS 0.46595f
C1180 XFRONT.XFE_O.VREGP.n7 VSS 1.65721f
C1181 XFRONT.XFE_O.VREGP.t13 VSS 0.46595f
C1182 XFRONT.XFE_O.VREGP.t12 VSS 0.46595f
C1183 XFRONT.XFE_O.VREGP.n8 VSS 1.64434f
C1184 XFRONT.XFE_O.VREGP.n9 VSS 0.83328f
C1185 XFRONT.XFE_O.VREGP.t11 VSS 0.46595f
C1186 XFRONT.XFE_O.VREGP.t10 VSS 0.46595f
C1187 XFRONT.XFE_O.VREGP.n10 VSS 1.64434f
C1188 XFRONT.XFE_O.VREGP.n11 VSS 0.47183f
C1189 XFRONT.XFE_O.VREGP.t9 VSS 0.46595f
C1190 XFRONT.XFE_O.VREGP.t8 VSS 0.46998f
C1191 XFRONT.XFE_O.VREGP.n12 VSS 1.64434f
C1192 XFRONT.XFE_O.VREGP.n13 VSS 2.23447f
C1193 XFRONT.XFE_O.VREGP.n14 VSS 1.85505f
C1194 XFRONT.XFE_O.SA.n0 VSS 0.13813f
C1195 XFRONT.XFE_O.SA.n1 VSS 0.08422f
C1196 XFRONT.XFE_O.SA.n2 VSS 0.29096f
C1197 XFRONT.XFE_O.SA.n3 VSS 0.15416f
C1198 XFRONT.XFE_O.SA.n4 VSS 0.29096f
C1199 XFRONT.XFE_O.SA.n5 VSS 0.14381f
C1200 XFRONT.XFE_O.SA.n6 VSS 0.15416f
C1201 XFRONT.XFE_O.SA.n7 VSS 0.42682f
C1202 XFRONT.XFE_O.SA.n8 VSS 0.21605f
C1203 XFRONT.XFE_O.SA.n9 VSS 0.20031f
C1204 XFRONT.XFE_O.SA.n10 VSS 0.15416f
C1205 XFRONT.XFE_O.SA.n11 VSS 0.15416f
C1206 XFRONT.XFE_O.SA.n12 VSS 0.20031f
C1207 XFRONT.XFE_O.SA.n13 VSS 0.14381f
C1208 XFRONT.XFE_O.SA.n14 VSS 0.42682f
C1209 XFRONT.XFE_O.SA.n15 VSS 0.21605f
C1210 XFRONT.XFE_O.SA.n16 VSS 0.15416f
C1211 XFRONT.XFE_O.SA.n17 VSS 0.15416f
C1212 XFRONT.XFE_O.SA.n18 VSS 0.08422f
C1213 XFRONT.XFE_O.SA.n19 VSS 0.06997f
C1214 XFRONT.XFE_O.SA.n20 VSS 1.7301f
C1215 XFRONT.XFE_O.SA.t0 VSS 2.0847f
C1216 XFRONT.XFE_O.SA.t6 VSS 1.28664f
C1217 XFRONT.XFE_O.SA.t5 VSS 1.27851f
C1218 XFRONT.XFE_O.SA.n21 VSS 0.7353f
C1219 XFRONT.XFE_O.SA.n22 VSS 2.83246f
C1220 XFRONT.XFE_O.SA.n23 VSS 3.3642f
C1221 XFRONT.XFE_O.SA.t4 VSS 1.28668f
C1222 XFRONT.XFE_O.SA.t3 VSS 1.27847f
C1223 XFRONT.XFE_O.SA.n24 VSS 1.33857f
C1224 XFRONT.XFE_O.SA.t2 VSS 1.17349f
C1225 XFRONT.XFE_O.SA.t1 VSS 1.1653f
C1226 XFRONT.XFE_O.SA.n25 VSS 0.49128f
C1227 XFRONT.XFE_O.SA.n26 VSS 1.53799f
C1228 XFRONT.XFE_O.SA.n27 VSS 0.73959f
C1229 XFRONT.XFE_O.SB.t3 VSS 1.23317f
C1230 XFRONT.XFE_O.SB.t4 VSS 1.22543f
C1231 XFRONT.XFE_O.SB.n0 VSS 1.08915f
C1232 XFRONT.XFE_O.SB.t2 VSS 1.13739f
C1233 XFRONT.XFE_O.SB.t1 VSS 1.12959f
C1234 XFRONT.XFE_O.SB.n1 VSS 0.46789f
C1235 XFRONT.XFE_O.SB.n2 VSS 1.54724f
C1236 XFRONT.XFE_O.SB.t0 VSS 2.07955f
C1237 XFRONT.XFE_O.SB.t5 VSS 0.33143f
C1238 XFRONT.XFE_O.SB.t6 VSS 0.33146f
C1239 XFRONT.XFE_O.SB.n3 VSS 1.07064f
C1240 XFRONT.XFE_O.SB.n4 VSS 2.8859f
C1241 XFRONT.XFE_O.SB.n5 VSS 2.80291f
C1242 XFRONT.XFE_O.SB.n6 VSS 0.13155f
C1243 XFRONT.XFE_O.SB.n7 VSS 0.08021f
C1244 XFRONT.XFE_O.SB.n8 VSS 0.2771f
C1245 XFRONT.XFE_O.SB.n9 VSS 0.14681f
C1246 XFRONT.XFE_O.SB.n10 VSS 0.2771f
C1247 XFRONT.XFE_O.SB.n11 VSS 0.13697f
C1248 XFRONT.XFE_O.SB.n12 VSS 0.14681f
C1249 XFRONT.XFE_O.SB.n13 VSS 0.40649f
C1250 XFRONT.XFE_O.SB.n14 VSS 0.20576f
C1251 XFRONT.XFE_O.SB.n15 VSS 0.19077f
C1252 XFRONT.XFE_O.SB.n16 VSS 0.14681f
C1253 XFRONT.XFE_O.SB.n17 VSS 0.14681f
C1254 XFRONT.XFE_O.SB.n18 VSS 0.19077f
C1255 XFRONT.XFE_O.SB.n19 VSS 0.13697f
C1256 XFRONT.XFE_O.SB.n20 VSS 0.40649f
C1257 XFRONT.XFE_O.SB.n21 VSS 0.20576f
C1258 XFRONT.XFE_O.SB.n22 VSS 0.14681f
C1259 XFRONT.XFE_O.SB.n23 VSS 0.14681f
C1260 XFRONT.XFE_O.SB.n24 VSS 0.08021f
C1261 XFRONT.XFE_O.SB.n25 VSS 0.06663f
C1262 XFRONT.XFE_O.SB.n26 VSS 0.97774f
C1263 XFRONT.XFE_O.SB.n27 VSS 1.27166f
C1264 XFRONT.XFE_O.VREGN.t15 VSS 2.05072f
C1265 XFRONT.XFE_O.VREGN.t14 VSS 0.43778f
C1266 XFRONT.XFE_O.VREGN.t13 VSS 0.43778f
C1267 XFRONT.XFE_O.VREGN.n0 VSS 1.55201f
C1268 XFRONT.XFE_O.VREGN.n1 VSS 0.76545f
C1269 XFRONT.XFE_O.VREGN.t8 VSS 2.05441f
C1270 XFRONT.XFE_O.VREGN.t10 VSS 0.43778f
C1271 XFRONT.XFE_O.VREGN.t9 VSS 0.43778f
C1272 XFRONT.XFE_O.VREGN.n2 VSS 1.55201f
C1273 XFRONT.XFE_O.VREGN.n3 VSS 0.85309f
C1274 XFRONT.XFE_O.VREGN.t12 VSS 0.43778f
C1275 XFRONT.XFE_O.VREGN.t11 VSS 0.43778f
C1276 XFRONT.XFE_O.VREGN.n4 VSS 1.55201f
C1277 XFRONT.XFE_O.VREGN.n5 VSS 0.35769f
C1278 XFRONT.XFE_O.VREGN.n6 VSS 0.70781f
C1279 XFRONT.XFE_O.VREGN.t1 VSS 0.44357f
C1280 XFRONT.XFE_O.VREGN.t0 VSS 0.44748f
C1281 XFRONT.XFE_O.VREGN.n7 VSS 1.56416f
C1282 XFRONT.XFE_O.VREGN.t3 VSS 0.44357f
C1283 XFRONT.XFE_O.VREGN.t2 VSS 0.44357f
C1284 XFRONT.XFE_O.VREGN.n8 VSS 1.55201f
C1285 XFRONT.XFE_O.VREGN.n9 VSS 0.78649f
C1286 XFRONT.XFE_O.VREGN.t5 VSS 0.44357f
C1287 XFRONT.XFE_O.VREGN.t4 VSS 0.44357f
C1288 XFRONT.XFE_O.VREGN.n10 VSS 1.55201f
C1289 XFRONT.XFE_O.VREGN.n11 VSS 0.44533f
C1290 XFRONT.XFE_O.VREGN.t7 VSS 0.44357f
C1291 XFRONT.XFE_O.VREGN.t6 VSS 0.44357f
C1292 XFRONT.XFE_O.VREGN.n12 VSS 1.55201f
C1293 XFRONT.XFE_O.VREGN.n13 VSS 1.47521f
C1294 XFRONT.XFE_O.VREGN.n14 VSS 1.97789f
C1295 XFRONT.XFE_E.XN.n0 VSS 0.18804f
C1296 XFRONT.XFE_E.XN.n1 VSS 0.38313f
C1297 XFRONT.XFE_E.XN.n2 VSS 0.13428f
C1298 XFRONT.XFE_E.XN.n3 VSS 0.2094f
C1299 XFRONT.XFE_E.XN.n4 VSS 0.19535f
C1300 XFRONT.XFE_E.XN.n5 VSS 0.57977f
C1301 XFRONT.XFE_E.XN.n6 VSS 0.28137f
C1302 XFRONT.XFE_E.XN.n7 VSS 0.2094f
C1303 XFRONT.XFE_E.XN.n8 VSS 0.2094f
C1304 XFRONT.XFE_E.XN.n9 VSS 0.2639f
C1305 XFRONT.XFE_E.XN.n10 VSS 0.29196f
C1306 XFRONT.XFE_E.XN.n11 VSS 0.29347f
C1307 XFRONT.XFE_E.XN.n12 VSS 0.57977f
C1308 XFRONT.XFE_E.XN.n13 VSS 0.19535f
C1309 XFRONT.XFE_E.XN.n14 VSS 0.39522f
C1310 XFRONT.XFE_E.XN.n15 VSS 0.2094f
C1311 XFRONT.XFE_E.XN.n16 VSS 0.2094f
C1312 XFRONT.XFE_E.XN.n17 VSS 0.2094f
C1313 XFRONT.XFE_E.XN.n18 VSS 0.10621f
C1314 XFRONT.XFE_E.XN.n19 VSS 0.09546f
C1315 XFRONT.XFE_E.XN.n20 VSS 1.55365f
C1316 XFRONT.XFE_E.XN.n21 VSS 0.19535f
C1317 XFRONT.XFE_E.XN.n22 VSS 0.2094f
C1318 XFRONT.XFE_E.XN.n23 VSS 0.1979f
C1319 XFRONT.XFE_E.XN.n24 VSS 1.02723f
C1320 XFRONT.XFE_E.XN.n25 VSS 1.79502f
C1321 XFRONT.XFE_E.XN.n26 VSS 0.10621f
C1322 XFRONT.XFE_E.XN.n27 VSS 0.2094f
C1323 XFRONT.XFE_E.XN.n28 VSS 0.39522f
C1324 XFRONT.XFE_E.XN.n29 VSS 0.19535f
C1325 XFRONT.XFE_E.XN.n30 VSS 0.2094f
C1326 XFRONT.XFE_E.XN.n31 VSS 0.2094f
C1327 XFRONT.XFE_E.XN.n32 VSS 0.2094f
C1328 XFRONT.XFE_E.XN.n33 VSS 0.13579f
C1329 XFRONT.XFE_E.XN.n34 VSS 0.13579f
C1330 XFRONT.XFE_E.XN.n35 VSS 0.13428f
C1331 XFRONT.XFE_E.XN.n36 VSS 0.2094f
C1332 XFRONT.XFE_E.XN.n37 VSS 0.2094f
C1333 XFRONT.XFE_E.XN.n38 VSS 0.19839f
C1334 XFRONT.XFE_E.XN.n39 VSS 0.25314f
C1335 XFRONT.XFE_E.XN.t1 VSS 1.6344f
C1336 XFRONT.XFE_E.XN.t4 VSS 0.34825f
C1337 XFRONT.XFE_E.XN.t2 VSS 0.34825f
C1338 XFRONT.XFE_E.XN.n40 VSS 1.22847f
C1339 XFRONT.XFE_E.XN.n41 VSS 0.62246f
C1340 XFRONT.XFE_E.XN.t0 VSS 1.6344f
C1341 XFRONT.XFE_E.XN.t34 VSS 0.34825f
C1342 XFRONT.XFE_E.XN.t3 VSS 0.34825f
C1343 XFRONT.XFE_E.XN.n42 VSS 1.22847f
C1344 XFRONT.XFE_E.XN.n43 VSS 0.69235f
C1345 XFRONT.XFE_E.XN.t33 VSS 0.34825f
C1346 XFRONT.XFE_E.XN.t5 VSS 0.34825f
C1347 XFRONT.XFE_E.XN.n44 VSS 1.22847f
C1348 XFRONT.XFE_E.XN.n45 VSS 0.29435f
C1349 XFRONT.XFE_E.XN.n46 VSS 0.21105f
C1350 XFRONT.XFE_E.XN.n47 VSS 0.39522f
C1351 XFRONT.XFE_E.XN.n48 VSS 0.19535f
C1352 XFRONT.XFE_E.XN.n49 VSS 0.2094f
C1353 XFRONT.XFE_E.XN.n50 VSS 0.2094f
C1354 XFRONT.XFE_E.XN.n51 VSS 0.1979f
C1355 XFRONT.XFE_E.XN.n52 VSS 0.3206f
C1356 XFRONT.XFE_E.XN.n53 VSS 0.71021f
C1357 XFRONT.XFE_E.XN.n54 VSS 0.87854f
C1358 XFRONT.XFE_E.XN.t29 VSS 1.67287f
C1359 XFRONT.XFE_E.XN.t24 VSS 0.38283f
C1360 XFRONT.XFE_E.XN.t23 VSS 0.38283f
C1361 XFRONT.XFE_E.XN.n55 VSS 1.2376f
C1362 XFRONT.XFE_E.XN.n56 VSS 0.68027f
C1363 XFRONT.XFE_E.XN.t22 VSS 0.38283f
C1364 XFRONT.XFE_E.XN.t27 VSS 0.38283f
C1365 XFRONT.XFE_E.XN.n57 VSS 1.2376f
C1366 XFRONT.XFE_E.XN.n58 VSS 0.33764f
C1367 XFRONT.XFE_E.XN.t28 VSS 1.66897f
C1368 XFRONT.XFE_E.XN.t26 VSS 0.38283f
C1369 XFRONT.XFE_E.XN.t25 VSS 0.38283f
C1370 XFRONT.XFE_E.XN.n59 VSS 1.2376f
C1371 XFRONT.XFE_E.XN.n60 VSS 0.55796f
C1372 XFRONT.XFE_E.XN.n61 VSS 0.69915f
C1373 XFRONT.XFE_E.XN.t31 VSS 0.4361f
C1374 XFRONT.XFE_E.XN.t30 VSS 0.4361f
C1375 XFRONT.XFE_E.XN.n62 VSS 1.23836f
C1376 XFRONT.XFE_E.XN.t32 VSS 1.71194f
C1377 XFRONT.XFE_E.XN.n63 VSS 0.969f
C1378 XFRONT.XFE_E.XN.n64 VSS 1.90694f
C1379 XFRONT.XFE_E.XN.n65 VSS 1.38561f
C1380 XFRONT.XFE_E.XN.t13 VSS 1.62732f
C1381 XFRONT.XFE_E.XN.t6 VSS 1.6301f
C1382 XFRONT.XFE_E.XN.t8 VSS 0.34118f
C1383 XFRONT.XFE_E.XN.t7 VSS 0.34118f
C1384 XFRONT.XFE_E.XN.n66 VSS 1.2376f
C1385 XFRONT.XFE_E.XN.n67 VSS 0.68027f
C1386 XFRONT.XFE_E.XN.t10 VSS 0.34118f
C1387 XFRONT.XFE_E.XN.t9 VSS 0.34118f
C1388 XFRONT.XFE_E.XN.n68 VSS 1.2376f
C1389 XFRONT.XFE_E.XN.n69 VSS 0.35512f
C1390 XFRONT.XFE_E.XN.t12 VSS 0.34118f
C1391 XFRONT.XFE_E.XN.t11 VSS 0.34118f
C1392 XFRONT.XFE_E.XN.n70 VSS 1.2376f
C1393 XFRONT.XFE_E.XN.n71 VSS 1.93393f
C1394 XFRONT.XFE_E.XN.n72 VSS 2.19485f
C1395 XFRONT.XFE_E.XN.t21 VSS 0.34118f
C1396 XFRONT.XFE_E.XN.t20 VSS 0.34118f
C1397 XFRONT.XFE_E.XN.n73 VSS 1.24729f
C1398 XFRONT.XFE_E.XN.t19 VSS 0.34118f
C1399 XFRONT.XFE_E.XN.t18 VSS 0.34118f
C1400 XFRONT.XFE_E.XN.n74 VSS 1.2376f
C1401 XFRONT.XFE_E.XN.n75 VSS 0.62716f
C1402 XFRONT.XFE_E.XN.t17 VSS 0.34118f
C1403 XFRONT.XFE_E.XN.t16 VSS 0.34118f
C1404 XFRONT.XFE_E.XN.n76 VSS 1.2376f
C1405 XFRONT.XFE_E.XN.n77 VSS 0.28523f
C1406 XFRONT.XFE_E.XN.t15 VSS 0.34118f
C1407 XFRONT.XFE_E.XN.t14 VSS 0.34396f
C1408 XFRONT.XFE_E.XN.n78 VSS 1.2413f
C1409 XFRONT.XFE_E.XN.n79 VSS 1.39559f
C1410 XFRONT.XFE_E.XN.n80 VSS 2.5705f
C1411 XFRONT.XFE_E.XP.n0 VSS 0.13162f
C1412 XFRONT.XFE_E.XP.n1 VSS 0.13162f
C1413 XFRONT.XFE_E.XP.n2 VSS 0.13162f
C1414 XFRONT.XFE_E.XP.n3 VSS 0.13162f
C1415 XFRONT.XFE_E.XP.n4 VSS 0.38311f
C1416 XFRONT.XFE_E.XP.n5 VSS 0.18936f
C1417 XFRONT.XFE_E.XP.n6 VSS 0.20298f
C1418 XFRONT.XFE_E.XP.n7 VSS 0.20298f
C1419 XFRONT.XFE_E.XP.n8 VSS 0.20298f
C1420 XFRONT.XFE_E.XP.n9 VSS 0.20298f
C1421 XFRONT.XFE_E.XP.n10 VSS 0.20298f
C1422 XFRONT.XFE_E.XP.n11 VSS 0.20298f
C1423 XFRONT.XFE_E.XP.n12 VSS 0.19184f
C1424 XFRONT.XFE_E.XP.n13 VSS 0.36751f
C1425 XFRONT.XFE_E.XP.t3 VSS 1.5824f
C1426 XFRONT.XFE_E.XP.t2 VSS 0.33573f
C1427 XFRONT.XFE_E.XP.t1 VSS 0.33573f
C1428 XFRONT.XFE_E.XP.n14 VSS 1.19081f
C1429 XFRONT.XFE_E.XP.n15 VSS 0.60338f
C1430 XFRONT.XFE_E.XP.t21 VSS 1.5824f
C1431 XFRONT.XFE_E.XP.t32 VSS 0.33573f
C1432 XFRONT.XFE_E.XP.t4 VSS 0.33573f
C1433 XFRONT.XFE_E.XP.n16 VSS 1.19081f
C1434 XFRONT.XFE_E.XP.n17 VSS 0.67112f
C1435 XFRONT.XFE_E.XP.t0 VSS 0.33573f
C1436 XFRONT.XFE_E.XP.t31 VSS 0.33573f
C1437 XFRONT.XFE_E.XP.n18 VSS 1.19081f
C1438 XFRONT.XFE_E.XP.n19 VSS 0.28533f
C1439 XFRONT.XFE_E.XP.n20 VSS 0.20458f
C1440 XFRONT.XFE_E.XP.n21 VSS 0.38311f
C1441 XFRONT.XFE_E.XP.n22 VSS 0.18936f
C1442 XFRONT.XFE_E.XP.n23 VSS 0.20298f
C1443 XFRONT.XFE_E.XP.n24 VSS 0.20298f
C1444 XFRONT.XFE_E.XP.n25 VSS 0.19184f
C1445 XFRONT.XFE_E.XP.n26 VSS 0.51601f
C1446 XFRONT.XFE_E.XP.n27 VSS 0.65345f
C1447 XFRONT.XFE_E.XP.n28 VSS 0.71994f
C1448 XFRONT.XFE_E.XP.n29 VSS 0.75743f
C1449 XFRONT.XFE_E.XP.n30 VSS 0.13162f
C1450 XFRONT.XFE_E.XP.n31 VSS 0.13162f
C1451 XFRONT.XFE_E.XP.n32 VSS 0.13162f
C1452 XFRONT.XFE_E.XP.n33 VSS 0.13162f
C1453 XFRONT.XFE_E.XP.n34 VSS 0.38311f
C1454 XFRONT.XFE_E.XP.n35 VSS 0.28447f
C1455 XFRONT.XFE_E.XP.n36 VSS 0.28447f
C1456 XFRONT.XFE_E.XP.n37 VSS 0.28447f
C1457 XFRONT.XFE_E.XP.n38 VSS 0.28447f
C1458 XFRONT.XFE_E.XP.n39 VSS 0.28447f
C1459 XFRONT.XFE_E.XP.n40 VSS 0.562f
C1460 XFRONT.XFE_E.XP.n41 VSS 0.18936f
C1461 XFRONT.XFE_E.XP.n42 VSS 0.20298f
C1462 XFRONT.XFE_E.XP.n43 VSS 0.20298f
C1463 XFRONT.XFE_E.XP.n44 VSS 0.20298f
C1464 XFRONT.XFE_E.XP.n45 VSS 0.20298f
C1465 XFRONT.XFE_E.XP.n46 VSS 0.20298f
C1466 XFRONT.XFE_E.XP.n47 VSS 0.20298f
C1467 XFRONT.XFE_E.XP.n48 VSS 0.19184f
C1468 XFRONT.XFE_E.XP.n49 VSS 0.51601f
C1469 XFRONT.XFE_E.XP.n50 VSS 1.57338f
C1470 XFRONT.XFE_E.XP.n51 VSS 0.18936f
C1471 XFRONT.XFE_E.XP.n52 VSS 0.20298f
C1472 XFRONT.XFE_E.XP.n53 VSS 0.19184f
C1473 XFRONT.XFE_E.XP.n54 VSS 0.96466f
C1474 XFRONT.XFE_E.XP.n55 VSS 2.41464f
C1475 XFRONT.XFE_E.XP.t13 VSS 1.58056f
C1476 XFRONT.XFE_E.XP.t20 VSS 0.33385f
C1477 XFRONT.XFE_E.XP.t19 VSS 0.33385f
C1478 XFRONT.XFE_E.XP.n56 VSS 1.19966f
C1479 XFRONT.XFE_E.XP.t14 VSS 1.58333f
C1480 XFRONT.XFE_E.XP.t16 VSS 0.33385f
C1481 XFRONT.XFE_E.XP.t15 VSS 0.33385f
C1482 XFRONT.XFE_E.XP.n57 VSS 1.19966f
C1483 XFRONT.XFE_E.XP.n58 VSS 0.65942f
C1484 XFRONT.XFE_E.XP.t18 VSS 0.33385f
C1485 XFRONT.XFE_E.XP.t17 VSS 0.33385f
C1486 XFRONT.XFE_E.XP.n59 VSS 1.19966f
C1487 XFRONT.XFE_E.XP.n60 VSS 0.34423f
C1488 XFRONT.XFE_E.XP.n61 VSS 1.91833f
C1489 XFRONT.XFE_E.XP.n62 VSS 3.62399f
C1490 XFRONT.XFE_E.XP.t12 VSS 1.58333f
C1491 XFRONT.XFE_E.XP.t11 VSS 0.33385f
C1492 XFRONT.XFE_E.XP.t10 VSS 0.33385f
C1493 XFRONT.XFE_E.XP.n63 VSS 1.19966f
C1494 XFRONT.XFE_E.XP.n64 VSS 0.65942f
C1495 XFRONT.XFE_E.XP.t9 VSS 0.33385f
C1496 XFRONT.XFE_E.XP.t8 VSS 0.33385f
C1497 XFRONT.XFE_E.XP.n65 VSS 1.19966f
C1498 XFRONT.XFE_E.XP.n66 VSS 0.34423f
C1499 XFRONT.XFE_E.XP.t5 VSS 1.58056f
C1500 XFRONT.XFE_E.XP.t7 VSS 0.33385f
C1501 XFRONT.XFE_E.XP.t6 VSS 0.33385f
C1502 XFRONT.XFE_E.XP.n67 VSS 1.19966f
C1503 XFRONT.XFE_E.XP.n68 VSS 1.91833f
C1504 XFRONT.XFE_E.XP.n69 VSS 2.33527f
C1505 XFRONT.XFE_E.XP.t26 VSS 1.63078f
C1506 XFRONT.XFE_E.XP.t34 VSS 0.38004f
C1507 XFRONT.XFE_E.XP.t25 VSS 0.38004f
C1508 XFRONT.XFE_E.XP.n70 VSS 1.19966f
C1509 XFRONT.XFE_E.XP.n71 VSS 0.65942f
C1510 XFRONT.XFE_E.XP.t28 VSS 0.38004f
C1511 XFRONT.XFE_E.XP.t33 VSS 0.38004f
C1512 XFRONT.XFE_E.XP.n72 VSS 1.19966f
C1513 XFRONT.XFE_E.XP.n73 VSS 0.34423f
C1514 XFRONT.XFE_E.XP.t30 VSS 0.38004f
C1515 XFRONT.XFE_E.XP.t27 VSS 0.38004f
C1516 XFRONT.XFE_E.XP.n74 VSS 1.19966f
C1517 XFRONT.XFE_E.XP.n75 VSS 0.34423f
C1518 XFRONT.XFE_E.XP.t29 VSS 1.62002f
C1519 XFRONT.XFE_E.XP.n76 VSS 1.13469f
C1520 XFRONT.XFE_E.XP.t23 VSS 0.435f
C1521 XFRONT.XFE_E.XP.t24 VSS 0.435f
C1522 XFRONT.XFE_E.XP.n77 VSS 1.2004f
C1523 XFRONT.XFE_E.XP.t22 VSS 1.67197f
C1524 XFRONT.XFE_E.XP.n78 VSS 0.90508f
C1525 XFRONT.XFE_E.XP.n79 VSS 1.85329f
C1526 XFRONT.XFE_E.XP.n80 VSS 1.03535f
C1527 XFRONT.XFE_O.XP.n0 VSS 0.75743f
C1528 XFRONT.XFE_O.XP.n1 VSS 0.13162f
C1529 XFRONT.XFE_O.XP.n2 VSS 0.20298f
C1530 XFRONT.XFE_O.XP.n3 VSS 0.28447f
C1531 XFRONT.XFE_O.XP.n4 VSS 0.20298f
C1532 XFRONT.XFE_O.XP.n5 VSS 0.13162f
C1533 XFRONT.XFE_O.XP.n6 VSS 0.18936f
C1534 XFRONT.XFE_O.XP.n7 VSS 0.20298f
C1535 XFRONT.XFE_O.XP.n8 VSS 0.562f
C1536 XFRONT.XFE_O.XP.n9 VSS 0.28447f
C1537 XFRONT.XFE_O.XP.n10 VSS 0.20298f
C1538 XFRONT.XFE_O.XP.n11 VSS 0.38311f
C1539 XFRONT.XFE_O.XP.n12 VSS 0.13162f
C1540 XFRONT.XFE_O.XP.n13 VSS 0.13162f
C1541 XFRONT.XFE_O.XP.n14 VSS 0.20298f
C1542 XFRONT.XFE_O.XP.n15 VSS 0.28447f
C1543 XFRONT.XFE_O.XP.n16 VSS 0.28447f
C1544 XFRONT.XFE_O.XP.n17 VSS 0.28447f
C1545 XFRONT.XFE_O.XP.n18 VSS 0.20298f
C1546 XFRONT.XFE_O.XP.n19 VSS 0.19184f
C1547 XFRONT.XFE_O.XP.n20 VSS 0.51601f
C1548 XFRONT.XFE_O.XP.n21 VSS 1.57338f
C1549 XFRONT.XFE_O.XP.n22 VSS 0.18936f
C1550 XFRONT.XFE_O.XP.n23 VSS 0.20298f
C1551 XFRONT.XFE_O.XP.n24 VSS 0.19184f
C1552 XFRONT.XFE_O.XP.n25 VSS 0.96466f
C1553 XFRONT.XFE_O.XP.n26 VSS 2.41464f
C1554 XFRONT.XFE_O.XP.t21 VSS 1.58333f
C1555 XFRONT.XFE_O.XP.t20 VSS 0.33385f
C1556 XFRONT.XFE_O.XP.t19 VSS 0.33385f
C1557 XFRONT.XFE_O.XP.n27 VSS 1.19966f
C1558 XFRONT.XFE_O.XP.n28 VSS 0.65942f
C1559 XFRONT.XFE_O.XP.t18 VSS 0.33385f
C1560 XFRONT.XFE_O.XP.t17 VSS 0.33385f
C1561 XFRONT.XFE_O.XP.n29 VSS 1.19966f
C1562 XFRONT.XFE_O.XP.n30 VSS 0.34423f
C1563 XFRONT.XFE_O.XP.t16 VSS 0.33385f
C1564 XFRONT.XFE_O.XP.t15 VSS 0.33385f
C1565 XFRONT.XFE_O.XP.n31 VSS 1.19966f
C1566 XFRONT.XFE_O.XP.t14 VSS 1.58056f
C1567 XFRONT.XFE_O.XP.n32 VSS 1.91833f
C1568 XFRONT.XFE_O.XP.n33 VSS 3.62399f
C1569 XFRONT.XFE_O.XP.t13 VSS 1.58056f
C1570 XFRONT.XFE_O.XP.t6 VSS 1.58333f
C1571 XFRONT.XFE_O.XP.t8 VSS 0.33385f
C1572 XFRONT.XFE_O.XP.t7 VSS 0.33385f
C1573 XFRONT.XFE_O.XP.n34 VSS 1.19966f
C1574 XFRONT.XFE_O.XP.n35 VSS 0.65942f
C1575 XFRONT.XFE_O.XP.t10 VSS 0.33385f
C1576 XFRONT.XFE_O.XP.t9 VSS 0.33385f
C1577 XFRONT.XFE_O.XP.n36 VSS 1.19966f
C1578 XFRONT.XFE_O.XP.n37 VSS 0.34423f
C1579 XFRONT.XFE_O.XP.t12 VSS 0.33385f
C1580 XFRONT.XFE_O.XP.t11 VSS 0.33385f
C1581 XFRONT.XFE_O.XP.n38 VSS 1.19966f
C1582 XFRONT.XFE_O.XP.n39 VSS 1.91833f
C1583 XFRONT.XFE_O.XP.n40 VSS 2.33527f
C1584 XFRONT.XFE_O.XP.t34 VSS 1.63078f
C1585 XFRONT.XFE_O.XP.t33 VSS 0.38004f
C1586 XFRONT.XFE_O.XP.t32 VSS 0.38004f
C1587 XFRONT.XFE_O.XP.n41 VSS 1.19966f
C1588 XFRONT.XFE_O.XP.n42 VSS 0.65942f
C1589 XFRONT.XFE_O.XP.t29 VSS 0.38004f
C1590 XFRONT.XFE_O.XP.t28 VSS 0.38004f
C1591 XFRONT.XFE_O.XP.n43 VSS 1.19966f
C1592 XFRONT.XFE_O.XP.n44 VSS 0.34423f
C1593 XFRONT.XFE_O.XP.t27 VSS 0.38004f
C1594 XFRONT.XFE_O.XP.t31 VSS 0.38004f
C1595 XFRONT.XFE_O.XP.n45 VSS 1.19966f
C1596 XFRONT.XFE_O.XP.n46 VSS 0.34423f
C1597 XFRONT.XFE_O.XP.t30 VSS 1.62002f
C1598 XFRONT.XFE_O.XP.n47 VSS 1.13469f
C1599 XFRONT.XFE_O.XP.t26 VSS 0.435f
C1600 XFRONT.XFE_O.XP.t25 VSS 0.435f
C1601 XFRONT.XFE_O.XP.n48 VSS 1.2004f
C1602 XFRONT.XFE_O.XP.t24 VSS 1.67197f
C1603 XFRONT.XFE_O.XP.n49 VSS 0.90508f
C1604 XFRONT.XFE_O.XP.n50 VSS 1.85329f
C1605 XFRONT.XFE_O.XP.n51 VSS 1.0456f
C1606 XFRONT.XFE_O.XP.n52 VSS 0.13162f
C1607 XFRONT.XFE_O.XP.n53 VSS 0.20298f
C1608 XFRONT.XFE_O.XP.n54 VSS 0.38311f
C1609 XFRONT.XFE_O.XP.n55 VSS 0.18936f
C1610 XFRONT.XFE_O.XP.n56 VSS 0.20298f
C1611 XFRONT.XFE_O.XP.n57 VSS 0.20298f
C1612 XFRONT.XFE_O.XP.n58 VSS 0.20298f
C1613 XFRONT.XFE_O.XP.n59 VSS 0.13162f
C1614 XFRONT.XFE_O.XP.n60 VSS 0.13162f
C1615 XFRONT.XFE_O.XP.n61 VSS 0.13162f
C1616 XFRONT.XFE_O.XP.n62 VSS 0.20298f
C1617 XFRONT.XFE_O.XP.n63 VSS 0.20298f
C1618 XFRONT.XFE_O.XP.n64 VSS 0.19184f
C1619 XFRONT.XFE_O.XP.n65 VSS 0.36751f
C1620 XFRONT.XFE_O.XP.t23 VSS 1.5824f
C1621 XFRONT.XFE_O.XP.t22 VSS 0.33573f
C1622 XFRONT.XFE_O.XP.t3 VSS 0.33573f
C1623 XFRONT.XFE_O.XP.n66 VSS 1.19081f
C1624 XFRONT.XFE_O.XP.n67 VSS 0.67112f
C1625 XFRONT.XFE_O.XP.t1 VSS 0.33573f
C1626 XFRONT.XFE_O.XP.t4 VSS 0.33573f
C1627 XFRONT.XFE_O.XP.n68 VSS 1.19081f
C1628 XFRONT.XFE_O.XP.n69 VSS 0.28533f
C1629 XFRONT.XFE_O.XP.t5 VSS 1.5824f
C1630 XFRONT.XFE_O.XP.t2 VSS 0.33573f
C1631 XFRONT.XFE_O.XP.t0 VSS 0.33573f
C1632 XFRONT.XFE_O.XP.n70 VSS 1.19081f
C1633 XFRONT.XFE_O.XP.n71 VSS 0.60338f
C1634 XFRONT.XFE_O.XP.n72 VSS 0.20458f
C1635 XFRONT.XFE_O.XP.n73 VSS 0.38311f
C1636 XFRONT.XFE_O.XP.n74 VSS 0.18936f
C1637 XFRONT.XFE_O.XP.n75 VSS 0.20298f
C1638 XFRONT.XFE_O.XP.n76 VSS 0.20298f
C1639 XFRONT.XFE_O.XP.n77 VSS 0.19184f
C1640 XFRONT.XFE_O.XP.n78 VSS 0.51601f
C1641 XFRONT.XFE_O.XP.n79 VSS 0.65345f
C1642 XFRONT.XFE_O.XP.n80 VSS 0.71951f
C1643 XFRONT.XFE_O.XP.n81 VSS 0.43054f
C1644 XFRONT.XFE_O.XN.n0 VSS 0.19839f
C1645 XFRONT.XFE_O.XN.n1 VSS 0.13428f
C1646 XFRONT.XFE_O.XN.n2 VSS 0.13579f
C1647 XFRONT.XFE_O.XN.n3 VSS 0.13579f
C1648 XFRONT.XFE_O.XN.n4 VSS 0.39522f
C1649 XFRONT.XFE_O.XN.n5 VSS 0.19535f
C1650 XFRONT.XFE_O.XN.n6 VSS 0.2094f
C1651 XFRONT.XFE_O.XN.n7 VSS 0.2094f
C1652 XFRONT.XFE_O.XN.n8 VSS 0.2094f
C1653 XFRONT.XFE_O.XN.n9 VSS 0.2094f
C1654 XFRONT.XFE_O.XN.n10 VSS 0.2094f
C1655 XFRONT.XFE_O.XN.n11 VSS 0.2094f
C1656 XFRONT.XFE_O.XN.n12 VSS 0.10621f
C1657 XFRONT.XFE_O.XN.n13 VSS 0.25314f
C1658 XFRONT.XFE_O.XN.t2 VSS 1.6344f
C1659 XFRONT.XFE_O.XN.t0 VSS 0.34825f
C1660 XFRONT.XFE_O.XN.t1 VSS 0.34825f
C1661 XFRONT.XFE_O.XN.n14 VSS 1.22847f
C1662 XFRONT.XFE_O.XN.n15 VSS 0.69235f
C1663 XFRONT.XFE_O.XN.t27 VSS 0.34825f
C1664 XFRONT.XFE_O.XN.t25 VSS 0.34825f
C1665 XFRONT.XFE_O.XN.n16 VSS 1.22847f
C1666 XFRONT.XFE_O.XN.n17 VSS 0.29435f
C1667 XFRONT.XFE_O.XN.t4 VSS 1.6344f
C1668 XFRONT.XFE_O.XN.t3 VSS 0.34825f
C1669 XFRONT.XFE_O.XN.t26 VSS 0.34825f
C1670 XFRONT.XFE_O.XN.n18 VSS 1.22847f
C1671 XFRONT.XFE_O.XN.n19 VSS 0.62246f
C1672 XFRONT.XFE_O.XN.n20 VSS 0.21105f
C1673 XFRONT.XFE_O.XN.n21 VSS 0.39522f
C1674 XFRONT.XFE_O.XN.n22 VSS 0.19535f
C1675 XFRONT.XFE_O.XN.n23 VSS 0.2094f
C1676 XFRONT.XFE_O.XN.n24 VSS 0.2094f
C1677 XFRONT.XFE_O.XN.n25 VSS 0.1979f
C1678 XFRONT.XFE_O.XN.n26 VSS 0.3206f
C1679 XFRONT.XFE_O.XN.n27 VSS 0.71021f
C1680 XFRONT.XFE_O.XN.n28 VSS 0.87854f
C1681 XFRONT.XFE_O.XN.t5 VSS 1.66897f
C1682 XFRONT.XFE_O.XN.t6 VSS 0.38283f
C1683 XFRONT.XFE_O.XN.t28 VSS 0.38283f
C1684 XFRONT.XFE_O.XN.n29 VSS 1.2376f
C1685 XFRONT.XFE_O.XN.n30 VSS 0.55796f
C1686 XFRONT.XFE_O.XN.t31 VSS 1.67287f
C1687 XFRONT.XFE_O.XN.t8 VSS 0.38283f
C1688 XFRONT.XFE_O.XN.t30 VSS 0.38283f
C1689 XFRONT.XFE_O.XN.n31 VSS 1.2376f
C1690 XFRONT.XFE_O.XN.n32 VSS 0.68027f
C1691 XFRONT.XFE_O.XN.t29 VSS 0.38283f
C1692 XFRONT.XFE_O.XN.t7 VSS 0.38283f
C1693 XFRONT.XFE_O.XN.n33 VSS 1.2376f
C1694 XFRONT.XFE_O.XN.n34 VSS 0.33764f
C1695 XFRONT.XFE_O.XN.n35 VSS 0.69915f
C1696 XFRONT.XFE_O.XN.t32 VSS 0.4361f
C1697 XFRONT.XFE_O.XN.t33 VSS 0.4361f
C1698 XFRONT.XFE_O.XN.n36 VSS 1.23836f
C1699 XFRONT.XFE_O.XN.t34 VSS 1.71194f
C1700 XFRONT.XFE_O.XN.n37 VSS 0.969f
C1701 XFRONT.XFE_O.XN.n38 VSS 1.90694f
C1702 XFRONT.XFE_O.XN.n39 VSS 1.38561f
C1703 XFRONT.XFE_O.XN.t16 VSS 1.6301f
C1704 XFRONT.XFE_O.XN.t15 VSS 0.34118f
C1705 XFRONT.XFE_O.XN.t14 VSS 0.34118f
C1706 XFRONT.XFE_O.XN.n40 VSS 1.2376f
C1707 XFRONT.XFE_O.XN.n41 VSS 0.68027f
C1708 XFRONT.XFE_O.XN.t13 VSS 0.34118f
C1709 XFRONT.XFE_O.XN.t12 VSS 0.34118f
C1710 XFRONT.XFE_O.XN.n42 VSS 1.2376f
C1711 XFRONT.XFE_O.XN.n43 VSS 0.35512f
C1712 XFRONT.XFE_O.XN.t9 VSS 1.62732f
C1713 XFRONT.XFE_O.XN.t11 VSS 0.34118f
C1714 XFRONT.XFE_O.XN.t10 VSS 0.34118f
C1715 XFRONT.XFE_O.XN.n44 VSS 1.2376f
C1716 XFRONT.XFE_O.XN.n45 VSS 1.93393f
C1717 XFRONT.XFE_O.XN.n46 VSS 2.19485f
C1718 XFRONT.XFE_O.XN.t22 VSS 0.34396f
C1719 XFRONT.XFE_O.XN.t21 VSS 0.34118f
C1720 XFRONT.XFE_O.XN.n47 VSS 1.2413f
C1721 XFRONT.XFE_O.XN.t24 VSS 0.34118f
C1722 XFRONT.XFE_O.XN.t23 VSS 0.34118f
C1723 XFRONT.XFE_O.XN.n48 VSS 1.24729f
C1724 XFRONT.XFE_O.XN.t18 VSS 0.34118f
C1725 XFRONT.XFE_O.XN.t17 VSS 0.34118f
C1726 XFRONT.XFE_O.XN.n49 VSS 1.2376f
C1727 XFRONT.XFE_O.XN.n50 VSS 0.62716f
C1728 XFRONT.XFE_O.XN.t20 VSS 0.34118f
C1729 XFRONT.XFE_O.XN.t19 VSS 0.34118f
C1730 XFRONT.XFE_O.XN.n51 VSS 1.2376f
C1731 XFRONT.XFE_O.XN.n52 VSS 0.28523f
C1732 XFRONT.XFE_O.XN.n53 VSS 1.39559f
C1733 XFRONT.XFE_O.XN.n54 VSS 2.58108f
C1734 XFRONT.XFE_O.XN.n55 VSS 0.18804f
C1735 XFRONT.XFE_O.XN.n56 VSS 0.10621f
C1736 XFRONT.XFE_O.XN.n57 VSS 0.19535f
C1737 XFRONT.XFE_O.XN.n58 VSS 0.2094f
C1738 XFRONT.XFE_O.XN.n59 VSS 0.2094f
C1739 XFRONT.XFE_O.XN.n60 VSS 0.57977f
C1740 XFRONT.XFE_O.XN.n61 VSS 0.13428f
C1741 XFRONT.XFE_O.XN.n62 VSS 0.39522f
C1742 XFRONT.XFE_O.XN.n63 VSS 0.19535f
C1743 XFRONT.XFE_O.XN.n64 VSS 0.2094f
C1744 XFRONT.XFE_O.XN.n65 VSS 0.2094f
C1745 XFRONT.XFE_O.XN.n66 VSS 0.29347f
C1746 XFRONT.XFE_O.XN.n67 VSS 0.29196f
C1747 XFRONT.XFE_O.XN.n68 VSS 0.2639f
C1748 XFRONT.XFE_O.XN.n69 VSS 0.2094f
C1749 XFRONT.XFE_O.XN.n70 VSS 0.57977f
C1750 XFRONT.XFE_O.XN.n71 VSS 0.28137f
C1751 XFRONT.XFE_O.XN.n72 VSS 0.2094f
C1752 XFRONT.XFE_O.XN.n73 VSS 0.38313f
C1753 XFRONT.XFE_O.XN.n74 VSS 0.09546f
C1754 XFRONT.XFE_O.XN.n75 VSS 1.55365f
C1755 XFRONT.XFE_O.XN.n76 VSS 0.19535f
C1756 XFRONT.XFE_O.XN.n77 VSS 0.2094f
C1757 XFRONT.XFE_O.XN.n78 VSS 0.1979f
C1758 XFRONT.XFE_O.XN.n79 VSS 1.02723f
C1759 XFRONT.XFE_O.XN.n80 VSS 1.79458f
C1760 XFRONT.XFE_O.XN.n81 VSS 1.07867f
C1761 XFRONT.XFE_E.NREGEN.t14 VSS 1.49455f
C1762 XFRONT.XFE_E.NREGEN.t13 VSS 1.48473f
C1763 XFRONT.XFE_E.NREGEN.n0 VSS 1.51825f
C1764 XFRONT.XFE_E.NREGEN.t8 VSS 0.31872f
C1765 XFRONT.XFE_E.NREGEN.t3 VSS 0.31589f
C1766 XFRONT.XFE_E.NREGEN.n1 VSS 1.09768f
C1767 XFRONT.XFE_E.NREGEN.t2 VSS 0.31589f
C1768 XFRONT.XFE_E.NREGEN.t1 VSS 0.31589f
C1769 XFRONT.XFE_E.NREGEN.n2 VSS 1.08892f
C1770 XFRONT.XFE_E.NREGEN.n3 VSS 0.57192f
C1771 XFRONT.XFE_E.NREGEN.t31 VSS 0.31589f
C1772 XFRONT.XFE_E.NREGEN.t33 VSS 0.31589f
C1773 XFRONT.XFE_E.NREGEN.n4 VSS 1.08892f
C1774 XFRONT.XFE_E.NREGEN.t9 VSS 0.31589f
C1775 XFRONT.XFE_E.NREGEN.t27 VSS 0.31872f
C1776 XFRONT.XFE_E.NREGEN.n5 VSS 1.09768f
C1777 XFRONT.XFE_E.NREGEN.n6 VSS 0.62125f
C1778 XFRONT.XFE_E.NREGEN.n7 VSS 1.81763f
C1779 XFRONT.XFE_E.NREGEN.t12 VSS 1.49455f
C1780 XFRONT.XFE_E.NREGEN.t11 VSS 1.48473f
C1781 XFRONT.XFE_E.NREGEN.n8 VSS 1.51825f
C1782 XFRONT.XFE_E.NREGEN.t4 VSS 0.32406f
C1783 XFRONT.XFE_E.NREGEN.t7 VSS 0.32109f
C1784 XFRONT.XFE_E.NREGEN.n9 VSS 1.09768f
C1785 XFRONT.XFE_E.NREGEN.t5 VSS 0.32109f
C1786 XFRONT.XFE_E.NREGEN.t26 VSS 0.32109f
C1787 XFRONT.XFE_E.NREGEN.n10 VSS 1.08892f
C1788 XFRONT.XFE_E.NREGEN.n11 VSS 0.57192f
C1789 XFRONT.XFE_E.NREGEN.t10 VSS 0.32109f
C1790 XFRONT.XFE_E.NREGEN.t32 VSS 0.32109f
C1791 XFRONT.XFE_E.NREGEN.n12 VSS 1.08892f
C1792 XFRONT.XFE_E.NREGEN.t6 VSS 0.32109f
C1793 XFRONT.XFE_E.NREGEN.t0 VSS 0.32406f
C1794 XFRONT.XFE_E.NREGEN.n13 VSS 1.09768f
C1795 XFRONT.XFE_E.NREGEN.n14 VSS 0.62125f
C1796 XFRONT.XFE_E.NREGEN.n15 VSS 1.92761f
C1797 XFRONT.XFE_E.NREGEN.t25 VSS 0.41272f
C1798 XFRONT.XFE_E.NREGEN.t23 VSS 0.40894f
C1799 XFRONT.XFE_E.NREGEN.n16 VSS 1.09768f
C1800 XFRONT.XFE_E.NREGEN.t24 VSS 1.5365f
C1801 XFRONT.XFE_E.NREGEN.n17 VSS 0.79737f
C1802 XFRONT.XFE_E.NREGEN.n18 VSS 2.26f
C1803 XFRONT.XFE_E.NREGEN.t22 VSS 1.49196f
C1804 XFRONT.XFE_E.NREGEN.t21 VSS 0.35186f
C1805 XFRONT.XFE_E.NREGEN.t20 VSS 0.35186f
C1806 XFRONT.XFE_E.NREGEN.n19 VSS 1.08892f
C1807 XFRONT.XFE_E.NREGEN.n20 VSS 0.55175f
C1808 XFRONT.XFE_E.NREGEN.t15 VSS 1.49196f
C1809 XFRONT.XFE_E.NREGEN.t17 VSS 0.35186f
C1810 XFRONT.XFE_E.NREGEN.t16 VSS 0.35186f
C1811 XFRONT.XFE_E.NREGEN.n21 VSS 1.08892f
C1812 XFRONT.XFE_E.NREGEN.n22 VSS 0.6137f
C1813 XFRONT.XFE_E.NREGEN.t19 VSS 0.35186f
C1814 XFRONT.XFE_E.NREGEN.t18 VSS 0.35186f
C1815 XFRONT.XFE_E.NREGEN.n23 VSS 1.08892f
C1816 XFRONT.XFE_E.NREGEN.n24 VSS 0.26092f
C1817 XFRONT.XFE_E.NREGEN.n25 VSS 0.19669f
C1818 XFRONT.XFE_E.NREGEN.n26 VSS 2.0413f
C1819 XFRONT.XFE_E.NREGEN.t28 VSS 0.41907f
C1820 XFRONT.XFE_E.NREGEN.t29 VSS 0.41517f
C1821 XFRONT.XFE_E.NREGEN.n27 VSS 1.09768f
C1822 XFRONT.XFE_E.NREGEN.t30 VSS 1.54273f
C1823 XFRONT.XFE_E.NREGEN.n28 VSS 0.79737f
C1824 XFRONT.XFE_E.NREGEN.n29 VSS 1.22864f
C1825 XFRONT.XFE_O.NREGEN.t17 VSS 1.48473f
C1826 XFRONT.XFE_O.NREGEN.t16 VSS 1.49455f
C1827 XFRONT.XFE_O.NREGEN.n0 VSS 1.51825f
C1828 XFRONT.XFE_O.NREGEN.t6 VSS 0.32406f
C1829 XFRONT.XFE_O.NREGEN.t1 VSS 0.32109f
C1830 XFRONT.XFE_O.NREGEN.n1 VSS 1.09768f
C1831 XFRONT.XFE_O.NREGEN.t2 VSS 0.32109f
C1832 XFRONT.XFE_O.NREGEN.t28 VSS 0.32109f
C1833 XFRONT.XFE_O.NREGEN.n2 VSS 1.08892f
C1834 XFRONT.XFE_O.NREGEN.t27 VSS 0.32109f
C1835 XFRONT.XFE_O.NREGEN.t8 VSS 0.32406f
C1836 XFRONT.XFE_O.NREGEN.n3 VSS 1.09768f
C1837 XFRONT.XFE_O.NREGEN.t26 VSS 0.32109f
C1838 XFRONT.XFE_O.NREGEN.t7 VSS 0.32109f
C1839 XFRONT.XFE_O.NREGEN.n4 VSS 1.08892f
C1840 XFRONT.XFE_O.NREGEN.n5 VSS 0.57192f
C1841 XFRONT.XFE_O.NREGEN.n6 VSS 0.62125f
C1842 XFRONT.XFE_O.NREGEN.n7 VSS 1.92761f
C1843 XFRONT.XFE_O.NREGEN.t32 VSS 0.40894f
C1844 XFRONT.XFE_O.NREGEN.t33 VSS 0.41272f
C1845 XFRONT.XFE_O.NREGEN.n8 VSS 1.09768f
C1846 XFRONT.XFE_O.NREGEN.t31 VSS 1.5365f
C1847 XFRONT.XFE_O.NREGEN.n9 VSS 0.79737f
C1848 XFRONT.XFE_O.NREGEN.n10 VSS 2.26f
C1849 XFRONT.XFE_O.NREGEN.t25 VSS 1.49196f
C1850 XFRONT.XFE_O.NREGEN.t24 VSS 0.35186f
C1851 XFRONT.XFE_O.NREGEN.t23 VSS 0.35186f
C1852 XFRONT.XFE_O.NREGEN.n11 VSS 1.08892f
C1853 XFRONT.XFE_O.NREGEN.n12 VSS 0.6137f
C1854 XFRONT.XFE_O.NREGEN.t22 VSS 0.35186f
C1855 XFRONT.XFE_O.NREGEN.t21 VSS 0.35186f
C1856 XFRONT.XFE_O.NREGEN.n13 VSS 1.08892f
C1857 XFRONT.XFE_O.NREGEN.n14 VSS 0.26092f
C1858 XFRONT.XFE_O.NREGEN.t18 VSS 1.49196f
C1859 XFRONT.XFE_O.NREGEN.t20 VSS 0.35186f
C1860 XFRONT.XFE_O.NREGEN.t19 VSS 0.35186f
C1861 XFRONT.XFE_O.NREGEN.n15 VSS 1.08892f
C1862 XFRONT.XFE_O.NREGEN.n16 VSS 0.55175f
C1863 XFRONT.XFE_O.NREGEN.n17 VSS 0.19669f
C1864 XFRONT.XFE_O.NREGEN.n18 VSS 2.0413f
C1865 XFRONT.XFE_O.NREGEN.t10 VSS 0.41517f
C1866 XFRONT.XFE_O.NREGEN.t11 VSS 0.41907f
C1867 XFRONT.XFE_O.NREGEN.n19 VSS 1.09768f
C1868 XFRONT.XFE_O.NREGEN.t13 VSS 1.54273f
C1869 XFRONT.XFE_O.NREGEN.n20 VSS 0.79737f
C1870 XFRONT.XFE_O.NREGEN.n21 VSS 1.23801f
C1871 XFRONT.XFE_O.NREGEN.t15 VSS 1.48473f
C1872 XFRONT.XFE_O.NREGEN.t14 VSS 1.49455f
C1873 XFRONT.XFE_O.NREGEN.n22 VSS 1.51825f
C1874 XFRONT.XFE_O.NREGEN.t30 VSS 0.31872f
C1875 XFRONT.XFE_O.NREGEN.t29 VSS 0.31589f
C1876 XFRONT.XFE_O.NREGEN.n23 VSS 1.09768f
C1877 XFRONT.XFE_O.NREGEN.t5 VSS 0.31589f
C1878 XFRONT.XFE_O.NREGEN.t3 VSS 0.31589f
C1879 XFRONT.XFE_O.NREGEN.n24 VSS 1.08892f
C1880 XFRONT.XFE_O.NREGEN.t0 VSS 0.31589f
C1881 XFRONT.XFE_O.NREGEN.t12 VSS 0.31872f
C1882 XFRONT.XFE_O.NREGEN.n25 VSS 1.09768f
C1883 XFRONT.XFE_O.NREGEN.t9 VSS 0.31589f
C1884 XFRONT.XFE_O.NREGEN.t4 VSS 0.31589f
C1885 XFRONT.XFE_O.NREGEN.n26 VSS 1.08892f
C1886 XFRONT.XFE_O.NREGEN.n27 VSS 0.57192f
C1887 XFRONT.XFE_O.NREGEN.n28 VSS 0.62125f
C1888 XFRONT.XFE_O.NREGEN.n29 VSS 1.81724f
C1889 XFRONT.XFE_O.NREGEN.n30 VSS 0.46869f
C1890 XFRONT.XFE_E.BN.t1 VSS 0.79219f
C1891 XFRONT.XFE_E.BN.t0 VSS 0.79713f
C1892 XFRONT.XFE_E.BN.n0 VSS 0.36943f
C1893 XFRONT.XFE_E.BN.t9 VSS 0.79583f
C1894 XFRONT.XFE_E.BN.t8 VSS 0.22254f
C1895 XFRONT.XFE_E.BN.t7 VSS 0.22254f
C1896 XFRONT.XFE_E.BN.n1 VSS 0.54671f
C1897 XFRONT.XFE_E.BN.n2 VSS 0.27702f
C1898 XFRONT.XFE_E.BN.t2 VSS 0.79583f
C1899 XFRONT.XFE_E.BN.t4 VSS 0.22254f
C1900 XFRONT.XFE_E.BN.t3 VSS 0.22254f
C1901 XFRONT.XFE_E.BN.n3 VSS 0.54671f
C1902 XFRONT.XFE_E.BN.n4 VSS 0.30812f
C1903 XFRONT.XFE_E.BN.t6 VSS 0.22254f
C1904 XFRONT.XFE_E.BN.t5 VSS 0.22254f
C1905 XFRONT.XFE_E.BN.n5 VSS 0.54671f
C1906 XFRONT.XFE_E.BN.n6 VSS 0.131f
C1907 XFRONT.XFE_E.BN.n7 VSS 0.15187f
C1908 XFRONT.XFE_E.BN.n8 VSS 0.54152f
C1909 XFRONT.XFE_E.BN.n9 VSS 0.05092f
C1910 XFRONT.XFE_E.BN.n10 VSS 0.17589f
C1911 XFRONT.XFE_E.BN.n11 VSS 0.08694f
C1912 XFRONT.XFE_E.BN.n12 VSS 0.09319f
C1913 XFRONT.XFE_E.BN.n13 VSS 0.09319f
C1914 XFRONT.XFE_E.BN.n14 VSS 0.09319f
C1915 XFRONT.XFE_E.BN.n15 VSS 0.08694f
C1916 XFRONT.XFE_E.BN.n16 VSS 0.17589f
C1917 XFRONT.XFE_E.BN.n17 VSS 0.09319f
C1918 XFRONT.XFE_E.BN.n18 VSS 0.09319f
C1919 XFRONT.XFE_E.BN.n19 VSS 0.09319f
C1920 XFRONT.XFE_E.BN.n20 VSS 0.05092f
C1921 XFRONT.XFE_E.BN.n21 VSS 0.04865f
C1922 XFRONT.XFE_E.BN.n22 VSS 0.06043f
C1923 XFRONT.XFE_E.BN.n23 VSS 0.06043f
C1924 XFRONT.XFE_E.BN.n24 VSS 0.17589f
C1925 XFRONT.XFE_E.BN.n25 VSS 0.08694f
C1926 XFRONT.XFE_E.BN.n26 VSS 0.09319f
C1927 XFRONT.XFE_E.BN.n27 VSS 0.09319f
C1928 XFRONT.XFE_E.BN.n28 VSS 0.09319f
C1929 XFRONT.XFE_E.BN.n29 VSS 0.09319f
C1930 XFRONT.XFE_E.BN.n30 VSS 0.08807f
C1931 XFRONT.XFE_E.BN.n31 VSS 0.27422f
C1932 XFRONT.XFE_E.BN.n32 VSS 0.6628f
C1933 XFRONT.XFE_E.SXN.t5 VSS 1.07869f
C1934 XFRONT.XFE_E.SXN.t6 VSS 0.33986f
C1935 XFRONT.XFE_E.SXN.t3 VSS 0.33986f
C1936 XFRONT.XFE_E.SXN.n0 VSS 0.70719f
C1937 XFRONT.XFE_E.SXN.n1 VSS 0.38872f
C1938 XFRONT.XFE_E.SXN.t4 VSS 0.33986f
C1939 XFRONT.XFE_E.SXN.t10 VSS 0.33986f
C1940 XFRONT.XFE_E.SXN.n2 VSS 0.70719f
C1941 XFRONT.XFE_E.SXN.n3 VSS 0.20292f
C1942 XFRONT.XFE_E.SXN.t11 VSS 0.33986f
C1943 XFRONT.XFE_E.SXN.t8 VSS 0.33986f
C1944 XFRONT.XFE_E.SXN.n4 VSS 0.70719f
C1945 XFRONT.XFE_E.SXN.n5 VSS 0.20292f
C1946 XFRONT.XFE_E.SXN.t9 VSS 1.06845f
C1947 XFRONT.XFE_E.SXN.n6 VSS 0.90335f
C1948 XFRONT.XFE_E.SXN.n7 VSS 0.42389f
C1949 XFRONT.XFE_E.SXN.n8 VSS 0.06537f
C1950 XFRONT.XFE_E.SXN.n9 VSS 0.22584f
C1951 XFRONT.XFE_E.SXN.n10 VSS 0.11163f
C1952 XFRONT.XFE_E.SXN.n11 VSS 0.11965f
C1953 XFRONT.XFE_E.SXN.n12 VSS 0.11965f
C1954 XFRONT.XFE_E.SXN.n13 VSS 0.11965f
C1955 XFRONT.XFE_E.SXN.n14 VSS 0.11163f
C1956 XFRONT.XFE_E.SXN.n15 VSS 0.22584f
C1957 XFRONT.XFE_E.SXN.n16 VSS 0.11965f
C1958 XFRONT.XFE_E.SXN.n17 VSS 0.11965f
C1959 XFRONT.XFE_E.SXN.n18 VSS 0.11965f
C1960 XFRONT.XFE_E.SXN.n19 VSS 0.06537f
C1961 XFRONT.XFE_E.SXN.n20 VSS 0.08065f
C1962 XFRONT.XFE_E.SXN.n21 VSS 1.52553f
C1963 XFRONT.XFE_E.SXN.t7 VSS 1.077f
C1964 XFRONT.XFE_E.SXN.t0 VSS 0.33986f
C1965 XFRONT.XFE_E.SXN.t1 VSS 0.33986f
C1966 XFRONT.XFE_E.SXN.n22 VSS 0.70198f
C1967 XFRONT.XFE_E.SXN.n23 VSS 0.39562f
C1968 XFRONT.XFE_E.SXN.t2 VSS 1.06675f
C1969 XFRONT.XFE_E.SXN.n24 VSS 0.93086f
C1970 XFRONT.XFE_E.SXN.n25 VSS 1.75356f
C1971 XFRONT.XFE_E.SXP.n0 VSS 0.44369f
C1972 XFRONT.XFE_E.SXP.n1 VSS 0.06633f
C1973 XFRONT.XFE_E.SXP.n2 VSS 0.22913f
C1974 XFRONT.XFE_E.SXP.n3 VSS 0.11325f
C1975 XFRONT.XFE_E.SXP.n4 VSS 0.1214f
C1976 XFRONT.XFE_E.SXP.n5 VSS 0.1214f
C1977 XFRONT.XFE_E.SXP.n6 VSS 0.1214f
C1978 XFRONT.XFE_E.SXP.n7 VSS 0.11325f
C1979 XFRONT.XFE_E.SXP.n8 VSS 0.22913f
C1980 XFRONT.XFE_E.SXP.n9 VSS 0.1214f
C1981 XFRONT.XFE_E.SXP.n10 VSS 0.1214f
C1982 XFRONT.XFE_E.SXP.n11 VSS 0.1214f
C1983 XFRONT.XFE_E.SXP.n12 VSS 0.06633f
C1984 XFRONT.XFE_E.SXP.n13 VSS 0.07275f
C1985 XFRONT.XFE_E.SXP.n14 VSS 0.88712f
C1986 XFRONT.XFE_E.SXP.t1 VSS 1.08502f
C1987 XFRONT.XFE_E.SXP.t11 VSS 0.33562f
C1988 XFRONT.XFE_E.SXP.t0 VSS 0.33562f
C1989 XFRONT.XFE_E.SXP.n15 VSS 0.71748f
C1990 XFRONT.XFE_E.SXP.n16 VSS 0.39438f
C1991 XFRONT.XFE_E.SXP.t9 VSS 0.33562f
C1992 XFRONT.XFE_E.SXP.t10 VSS 0.33562f
C1993 XFRONT.XFE_E.SXP.n17 VSS 0.71748f
C1994 XFRONT.XFE_E.SXP.n18 VSS 0.20587f
C1995 XFRONT.XFE_E.SXP.t3 VSS 0.33562f
C1996 XFRONT.XFE_E.SXP.t4 VSS 0.33562f
C1997 XFRONT.XFE_E.SXP.n19 VSS 0.71748f
C1998 XFRONT.XFE_E.SXP.n20 VSS 0.20587f
C1999 XFRONT.XFE_E.SXP.t2 VSS 1.07481f
C2000 XFRONT.XFE_E.SXP.n21 VSS 0.5855f
C2001 XFRONT.XFE_E.SXP.t8 VSS 1.08331f
C2002 XFRONT.XFE_E.SXP.t6 VSS 0.33562f
C2003 XFRONT.XFE_E.SXP.t7 VSS 0.33562f
C2004 XFRONT.XFE_E.SXP.n22 VSS 0.71219f
C2005 XFRONT.XFE_E.SXP.n23 VSS 0.40138f
C2006 XFRONT.XFE_E.SXP.t5 VSS 1.07309f
C2007 XFRONT.XFE_E.SXP.n24 VSS 0.57887f
C2008 XFRONT.XFE_E.SXP.n25 VSS 1.39041f
C2009 XFRONT.XFE_E.BP.n0 VSS 0.04911f
C2010 XFRONT.XFE_E.BP.n1 VSS 0.16966f
C2011 XFRONT.XFE_E.BP.n2 VSS 0.08386f
C2012 XFRONT.XFE_E.BP.n3 VSS 0.08989f
C2013 XFRONT.XFE_E.BP.n4 VSS 0.08989f
C2014 XFRONT.XFE_E.BP.n5 VSS 0.08989f
C2015 XFRONT.XFE_E.BP.n6 VSS 0.08386f
C2016 XFRONT.XFE_E.BP.n7 VSS 0.16966f
C2017 XFRONT.XFE_E.BP.n8 VSS 0.08989f
C2018 XFRONT.XFE_E.BP.n9 VSS 0.08989f
C2019 XFRONT.XFE_E.BP.n10 VSS 0.08989f
C2020 XFRONT.XFE_E.BP.n11 VSS 0.04911f
C2021 XFRONT.XFE_E.BP.n12 VSS 0.05215f
C2022 XFRONT.XFE_E.BP.n13 VSS 0.05829f
C2023 XFRONT.XFE_E.BP.n14 VSS 0.08989f
C2024 XFRONT.XFE_E.BP.n15 VSS 0.08989f
C2025 XFRONT.XFE_E.BP.n16 VSS 0.08386f
C2026 XFRONT.XFE_E.BP.n17 VSS 0.16966f
C2027 XFRONT.XFE_E.BP.n18 VSS 0.05829f
C2028 XFRONT.XFE_E.BP.n19 VSS 0.08989f
C2029 XFRONT.XFE_E.BP.n20 VSS 0.08989f
C2030 XFRONT.XFE_E.BP.n21 VSS 0.08495f
C2031 XFRONT.XFE_E.BP.n22 VSS 0.25147f
C2032 XFRONT.XFE_E.BP.n23 VSS 0.57807f
C2033 XFRONT.XFE_E.BP.t8 VSS 0.77005f
C2034 XFRONT.XFE_E.BP.t9 VSS 0.77482f
C2035 XFRONT.XFE_E.BP.n24 VSS 0.37042f
C2036 XFRONT.XFE_E.BP.t0 VSS 0.77356f
C2037 XFRONT.XFE_E.BP.t1 VSS 0.22046f
C2038 XFRONT.XFE_E.BP.t2 VSS 0.22046f
C2039 XFRONT.XFE_E.BP.n25 VSS 0.52735f
C2040 XFRONT.XFE_E.BP.n26 VSS 0.26721f
C2041 XFRONT.XFE_E.BP.t7 VSS 0.77356f
C2042 XFRONT.XFE_E.BP.t5 VSS 0.22046f
C2043 XFRONT.XFE_E.BP.t6 VSS 0.22046f
C2044 XFRONT.XFE_E.BP.n27 VSS 0.52735f
C2045 XFRONT.XFE_E.BP.n28 VSS 0.29721f
C2046 XFRONT.XFE_E.BP.t3 VSS 0.22046f
C2047 XFRONT.XFE_E.BP.t4 VSS 0.22046f
C2048 XFRONT.XFE_E.BP.n29 VSS 0.52735f
C2049 XFRONT.XFE_E.BP.n30 VSS 0.12636f
C2050 XFRONT.XFE_E.BP.n31 VSS 0.13242f
C2051 XFRONT.XFE_E.BP.n32 VSS 0.57347f
C2052 XFRONT.XFE_O.BP.t1 VSS 0.77482f
C2053 XFRONT.XFE_O.BP.t0 VSS 0.77005f
C2054 XFRONT.XFE_O.BP.n0 VSS 0.37042f
C2055 XFRONT.XFE_O.BP.t9 VSS 0.77356f
C2056 XFRONT.XFE_O.BP.t8 VSS 0.22046f
C2057 XFRONT.XFE_O.BP.t7 VSS 0.22046f
C2058 XFRONT.XFE_O.BP.n1 VSS 0.52735f
C2059 XFRONT.XFE_O.BP.n2 VSS 0.29721f
C2060 XFRONT.XFE_O.BP.t6 VSS 0.22046f
C2061 XFRONT.XFE_O.BP.t5 VSS 0.22046f
C2062 XFRONT.XFE_O.BP.n3 VSS 0.52735f
C2063 XFRONT.XFE_O.BP.n4 VSS 0.12636f
C2064 XFRONT.XFE_O.BP.t2 VSS 0.77356f
C2065 XFRONT.XFE_O.BP.t4 VSS 0.22046f
C2066 XFRONT.XFE_O.BP.t3 VSS 0.22046f
C2067 XFRONT.XFE_O.BP.n5 VSS 0.52735f
C2068 XFRONT.XFE_O.BP.n6 VSS 0.26721f
C2069 XFRONT.XFE_O.BP.n7 VSS 0.13242f
C2070 XFRONT.XFE_O.BP.n8 VSS 0.57561f
C2071 XFRONT.XFE_O.BP.n9 VSS 0.04911f
C2072 XFRONT.XFE_O.BP.n10 VSS 0.16966f
C2073 XFRONT.XFE_O.BP.n11 VSS 0.08386f
C2074 XFRONT.XFE_O.BP.n12 VSS 0.08989f
C2075 XFRONT.XFE_O.BP.n13 VSS 0.08989f
C2076 XFRONT.XFE_O.BP.n14 VSS 0.08989f
C2077 XFRONT.XFE_O.BP.n15 VSS 0.08386f
C2078 XFRONT.XFE_O.BP.n16 VSS 0.16966f
C2079 XFRONT.XFE_O.BP.n17 VSS 0.08989f
C2080 XFRONT.XFE_O.BP.n18 VSS 0.08989f
C2081 XFRONT.XFE_O.BP.n19 VSS 0.08989f
C2082 XFRONT.XFE_O.BP.n20 VSS 0.04911f
C2083 XFRONT.XFE_O.BP.n21 VSS 0.05215f
C2084 XFRONT.XFE_O.BP.n22 VSS 0.05829f
C2085 XFRONT.XFE_O.BP.n23 VSS 0.05829f
C2086 XFRONT.XFE_O.BP.n24 VSS 0.16966f
C2087 XFRONT.XFE_O.BP.n25 VSS 0.08386f
C2088 XFRONT.XFE_O.BP.n26 VSS 0.08989f
C2089 XFRONT.XFE_O.BP.n27 VSS 0.08989f
C2090 XFRONT.XFE_O.BP.n28 VSS 0.08989f
C2091 XFRONT.XFE_O.BP.n29 VSS 0.08989f
C2092 XFRONT.XFE_O.BP.n30 VSS 0.08495f
C2093 XFRONT.XFE_O.BP.n31 VSS 0.25147f
C2094 XFRONT.XFE_O.BP.n32 VSS 0.57788f
C2095 XFRONT.XFE_O.BP.n33 VSS 0.34059f
C2096 XFRONT.XFE_O.SXP.t4 VSS 1.08502f
C2097 XFRONT.XFE_O.SXP.t5 VSS 0.33562f
C2098 XFRONT.XFE_O.SXP.t10 VSS 0.33562f
C2099 XFRONT.XFE_O.SXP.n0 VSS 0.71748f
C2100 XFRONT.XFE_O.SXP.n1 VSS 0.39438f
C2101 XFRONT.XFE_O.SXP.t11 VSS 0.33562f
C2102 XFRONT.XFE_O.SXP.t0 VSS 0.33562f
C2103 XFRONT.XFE_O.SXP.n2 VSS 0.71748f
C2104 XFRONT.XFE_O.SXP.n3 VSS 0.20587f
C2105 XFRONT.XFE_O.SXP.t1 VSS 0.33562f
C2106 XFRONT.XFE_O.SXP.t2 VSS 0.33562f
C2107 XFRONT.XFE_O.SXP.n4 VSS 0.71748f
C2108 XFRONT.XFE_O.SXP.n5 VSS 0.20587f
C2109 XFRONT.XFE_O.SXP.t3 VSS 1.07481f
C2110 XFRONT.XFE_O.SXP.n6 VSS 0.5855f
C2111 XFRONT.XFE_O.SXP.t6 VSS 1.08331f
C2112 XFRONT.XFE_O.SXP.t7 VSS 0.33562f
C2113 XFRONT.XFE_O.SXP.t8 VSS 0.33562f
C2114 XFRONT.XFE_O.SXP.n7 VSS 0.71219f
C2115 XFRONT.XFE_O.SXP.n8 VSS 0.40138f
C2116 XFRONT.XFE_O.SXP.t9 VSS 1.07309f
C2117 XFRONT.XFE_O.SXP.n9 VSS 0.57887f
C2118 XFRONT.XFE_O.SXP.n10 VSS 1.39499f
C2119 XFRONT.XFE_O.SXP.n11 VSS 0.44369f
C2120 XFRONT.XFE_O.SXP.n12 VSS 0.06633f
C2121 XFRONT.XFE_O.SXP.n13 VSS 0.22913f
C2122 XFRONT.XFE_O.SXP.n14 VSS 0.11325f
C2123 XFRONT.XFE_O.SXP.n15 VSS 0.1214f
C2124 XFRONT.XFE_O.SXP.n16 VSS 0.1214f
C2125 XFRONT.XFE_O.SXP.n17 VSS 0.1214f
C2126 XFRONT.XFE_O.SXP.n18 VSS 0.11325f
C2127 XFRONT.XFE_O.SXP.n19 VSS 0.22913f
C2128 XFRONT.XFE_O.SXP.n20 VSS 0.1214f
C2129 XFRONT.XFE_O.SXP.n21 VSS 0.1214f
C2130 XFRONT.XFE_O.SXP.n22 VSS 0.1214f
C2131 XFRONT.XFE_O.SXP.n23 VSS 0.06633f
C2132 XFRONT.XFE_O.SXP.n24 VSS 0.07275f
C2133 XFRONT.XFE_O.SXP.n25 VSS 0.88687f
C2134 XFRONT.XFE_O.SXP.n26 VSS 1.78078f
C2135 XFRONT.XFE_O.SXN.n0 VSS 0.42389f
C2136 XFRONT.XFE_O.SXN.n1 VSS 0.06537f
C2137 XFRONT.XFE_O.SXN.n2 VSS 0.22584f
C2138 XFRONT.XFE_O.SXN.n3 VSS 0.11163f
C2139 XFRONT.XFE_O.SXN.n4 VSS 0.11965f
C2140 XFRONT.XFE_O.SXN.n5 VSS 0.11965f
C2141 XFRONT.XFE_O.SXN.n6 VSS 0.11965f
C2142 XFRONT.XFE_O.SXN.n7 VSS 0.11163f
C2143 XFRONT.XFE_O.SXN.n8 VSS 0.22584f
C2144 XFRONT.XFE_O.SXN.n9 VSS 0.11965f
C2145 XFRONT.XFE_O.SXN.n10 VSS 0.11965f
C2146 XFRONT.XFE_O.SXN.n11 VSS 0.11965f
C2147 XFRONT.XFE_O.SXN.n12 VSS 0.06537f
C2148 XFRONT.XFE_O.SXN.n13 VSS 0.08065f
C2149 XFRONT.XFE_O.SXN.n14 VSS 1.52553f
C2150 XFRONT.XFE_O.SXN.t11 VSS 1.077f
C2151 XFRONT.XFE_O.SXN.t9 VSS 0.33986f
C2152 XFRONT.XFE_O.SXN.t10 VSS 0.33986f
C2153 XFRONT.XFE_O.SXN.n15 VSS 0.70198f
C2154 XFRONT.XFE_O.SXN.n16 VSS 0.39562f
C2155 XFRONT.XFE_O.SXN.t0 VSS 1.06675f
C2156 XFRONT.XFE_O.SXN.n17 VSS 0.93086f
C2157 XFRONT.XFE_O.SXN.n18 VSS 1.75961f
C2158 XFRONT.XFE_O.SXN.t2 VSS 1.07869f
C2159 XFRONT.XFE_O.SXN.t8 VSS 0.33986f
C2160 XFRONT.XFE_O.SXN.t1 VSS 0.33986f
C2161 XFRONT.XFE_O.SXN.n19 VSS 0.70719f
C2162 XFRONT.XFE_O.SXN.n20 VSS 0.38872f
C2163 XFRONT.XFE_O.SXN.t6 VSS 0.33986f
C2164 XFRONT.XFE_O.SXN.t7 VSS 0.33986f
C2165 XFRONT.XFE_O.SXN.n21 VSS 0.70719f
C2166 XFRONT.XFE_O.SXN.n22 VSS 0.20292f
C2167 XFRONT.XFE_O.SXN.t4 VSS 0.33986f
C2168 XFRONT.XFE_O.SXN.t5 VSS 0.33986f
C2169 XFRONT.XFE_O.SXN.n23 VSS 0.70719f
C2170 XFRONT.XFE_O.SXN.n24 VSS 0.20292f
C2171 XFRONT.XFE_O.SXN.t3 VSS 1.06845f
C2172 XFRONT.XFE_O.SXN.n25 VSS 0.90216f
C2173 XFRONT.XFE_O.SXN.n26 VSS 0.5459f
C2174 XFRONT.XFE_O.BN.n0 VSS 0.05092f
C2175 XFRONT.XFE_O.BN.n1 VSS 0.17589f
C2176 XFRONT.XFE_O.BN.n2 VSS 0.08694f
C2177 XFRONT.XFE_O.BN.n3 VSS 0.09319f
C2178 XFRONT.XFE_O.BN.n4 VSS 0.09319f
C2179 XFRONT.XFE_O.BN.n5 VSS 0.09319f
C2180 XFRONT.XFE_O.BN.n6 VSS 0.08694f
C2181 XFRONT.XFE_O.BN.n7 VSS 0.17589f
C2182 XFRONT.XFE_O.BN.n8 VSS 0.09319f
C2183 XFRONT.XFE_O.BN.n9 VSS 0.09319f
C2184 XFRONT.XFE_O.BN.n10 VSS 0.09319f
C2185 XFRONT.XFE_O.BN.n11 VSS 0.05092f
C2186 XFRONT.XFE_O.BN.n12 VSS 0.04865f
C2187 XFRONT.XFE_O.BN.n13 VSS 0.06043f
C2188 XFRONT.XFE_O.BN.n14 VSS 0.09319f
C2189 XFRONT.XFE_O.BN.n15 VSS 0.09319f
C2190 XFRONT.XFE_O.BN.n16 VSS 0.08694f
C2191 XFRONT.XFE_O.BN.n17 VSS 0.17589f
C2192 XFRONT.XFE_O.BN.n18 VSS 0.06043f
C2193 XFRONT.XFE_O.BN.n19 VSS 0.09319f
C2194 XFRONT.XFE_O.BN.n20 VSS 0.09319f
C2195 XFRONT.XFE_O.BN.n21 VSS 0.08807f
C2196 XFRONT.XFE_O.BN.n22 VSS 0.27422f
C2197 XFRONT.XFE_O.BN.n23 VSS 0.66526f
C2198 XFRONT.XFE_O.BN.t1 VSS 0.79713f
C2199 XFRONT.XFE_O.BN.t2 VSS 0.79219f
C2200 XFRONT.XFE_O.BN.n24 VSS 0.36943f
C2201 XFRONT.XFE_O.BN.t7 VSS 0.79583f
C2202 XFRONT.XFE_O.BN.t8 VSS 0.22254f
C2203 XFRONT.XFE_O.BN.t9 VSS 0.22254f
C2204 XFRONT.XFE_O.BN.n25 VSS 0.54671f
C2205 XFRONT.XFE_O.BN.n26 VSS 0.30812f
C2206 XFRONT.XFE_O.BN.t3 VSS 0.22254f
C2207 XFRONT.XFE_O.BN.t4 VSS 0.22254f
C2208 XFRONT.XFE_O.BN.n27 VSS 0.54671f
C2209 XFRONT.XFE_O.BN.n28 VSS 0.131f
C2210 XFRONT.XFE_O.BN.t0 VSS 0.79583f
C2211 XFRONT.XFE_O.BN.t5 VSS 0.22254f
C2212 XFRONT.XFE_O.BN.t6 VSS 0.22254f
C2213 XFRONT.XFE_O.BN.n29 VSS 0.54671f
C2214 XFRONT.XFE_O.BN.n30 VSS 0.27702f
C2215 XFRONT.XFE_O.BN.n31 VSS 0.15187f
C2216 XFRONT.XFE_O.BN.n32 VSS 0.54133f
C2217 XFRONT.XFE_O.BN.n33 VSS 0.40957f
C2218 XFRONT.XFE_E.NTAIL.t11 VSS 0.17332f
C2219 XFRONT.XFE_E.NTAIL.t10 VSS 0.17332f
C2220 XFRONT.XFE_E.NTAIL.n0 VSS 0.91027f
C2221 XFRONT.XFE_E.NTAIL.t2 VSS 0.19081f
C2222 XFRONT.XFE_E.NTAIL.t3 VSS 0.19081f
C2223 XFRONT.XFE_E.NTAIL.n1 VSS 0.97526f
C2224 XFRONT.XFE_E.NTAIL.t1 VSS 0.92647f
C2225 XFRONT.XFE_E.NTAIL.t0 VSS 0.93208f
C2226 XFRONT.XFE_E.NTAIL.n2 VSS 0.44321f
C2227 XFRONT.XFE_E.NTAIL.n3 VSS 1.31879f
C2228 XFRONT.XFE_E.NTAIL.t9 VSS 0.84943f
C2229 XFRONT.XFE_E.NTAIL.t4 VSS 0.85119f
C2230 XFRONT.XFE_E.NTAIL.t6 VSS 0.20358f
C2231 XFRONT.XFE_E.NTAIL.t5 VSS 0.20358f
C2232 XFRONT.XFE_E.NTAIL.n4 VSS 0.61999f
C2233 XFRONT.XFE_E.NTAIL.n5 VSS 0.34942f
C2234 XFRONT.XFE_E.NTAIL.t8 VSS 0.20358f
C2235 XFRONT.XFE_E.NTAIL.t7 VSS 0.20358f
C2236 XFRONT.XFE_E.NTAIL.n6 VSS 0.61999f
C2237 XFRONT.XFE_E.NTAIL.n7 VSS 0.14856f
C2238 XFRONT.XFE_E.NTAIL.n8 VSS 0.31063f
C2239 XFRONT.XFE_E.NTAIL.n9 VSS 0.61878f
C2240 XFRONT.XFE_O.NTAIL.t8 VSS 0.19075f
C2241 XFRONT.XFE_O.NTAIL.t9 VSS 0.19075f
C2242 XFRONT.XFE_O.NTAIL.n0 VSS 0.97526f
C2243 XFRONT.XFE_O.NTAIL.t11 VSS 0.93208f
C2244 XFRONT.XFE_O.NTAIL.t10 VSS 0.92647f
C2245 XFRONT.XFE_O.NTAIL.n1 VSS 0.44321f
C2246 XFRONT.XFE_O.NTAIL.n2 VSS 1.31879f
C2247 XFRONT.XFE_O.NTAIL.t5 VSS 0.85119f
C2248 XFRONT.XFE_O.NTAIL.t4 VSS 0.20358f
C2249 XFRONT.XFE_O.NTAIL.t3 VSS 0.20358f
C2250 XFRONT.XFE_O.NTAIL.n3 VSS 0.61999f
C2251 XFRONT.XFE_O.NTAIL.n4 VSS 0.34942f
C2252 XFRONT.XFE_O.NTAIL.t2 VSS 0.20358f
C2253 XFRONT.XFE_O.NTAIL.t1 VSS 0.20358f
C2254 XFRONT.XFE_O.NTAIL.n5 VSS 0.61999f
C2255 XFRONT.XFE_O.NTAIL.n6 VSS 0.14856f
C2256 XFRONT.XFE_O.NTAIL.t0 VSS 0.84943f
C2257 XFRONT.XFE_O.NTAIL.n7 VSS 0.31063f
C2258 XFRONT.XFE_O.NTAIL.n8 VSS 0.62412f
C2259 XFRONT.XFE_O.NTAIL.t6 VSS 0.17348f
C2260 XFRONT.XFE_O.NTAIL.t7 VSS 0.17348f
C2261 XFRONT.XFE_O.NTAIL.n9 VSS 0.90948f
C2262 XFRONT.XFE_O.NTAIL.n10 VSS 0.53201f
C2263 a_948_44200.t5 VSS 0.63799f
C2264 a_948_44200.t1 VSS 0.1331f
C2265 a_948_44200.t0 VSS 0.1331f
C2266 a_948_44200.n0 VSS 0.51748f
C2267 a_948_44200.t3 VSS 0.13204f
C2268 a_948_44200.t2 VSS 0.13204f
C2269 a_948_44200.n1 VSS 0.47973f
C2270 a_948_44200.n2 VSS 3.66241f
C2271 a_948_44200.n3 VSS 0.50661f
C2272 a_948_44200.t4 VSS 0.63799f
C2273 a_2548_44200.t2 VSS 0.84552f
C2274 a_2548_44200.t5 VSS 0.16249f
C2275 a_2548_44200.t4 VSS 0.16249f
C2276 a_2548_44200.n0 VSS 0.62947f
C2277 a_2548_44200.t1 VSS 0.17593f
C2278 a_2548_44200.t0 VSS 0.17593f
C2279 a_2548_44200.n1 VSS 0.59103f
C2280 a_2548_44200.n2 VSS 2.81846f
C2281 a_2548_44200.n3 VSS 0.69295f
C2282 a_2548_44200.t3 VSS 0.84552f
C2283 a_10548_44200.t5 VSS 0.61673f
C2284 a_10548_44200.t1 VSS 0.13032f
C2285 a_10548_44200.t0 VSS 0.13032f
C2286 a_10548_44200.n0 VSS 0.50161f
C2287 a_10548_44200.t3 VSS 0.12927f
C2288 a_10548_44200.t2 VSS 0.12927f
C2289 a_10548_44200.n1 VSS 0.46501f
C2290 a_10548_44200.n2 VSS 3.55006f
C2291 a_10548_44200.n3 VSS 0.49107f
C2292 a_10548_44200.t4 VSS 0.61673f
C2293 a_12148_44200.t5 VSS 0.83953f
C2294 a_12148_44200.t3 VSS 0.17456f
C2295 a_12148_44200.t2 VSS 0.17456f
C2296 a_12148_44200.n0 VSS 0.62265f
C2297 a_12148_44200.t1 VSS 0.16129f
C2298 a_12148_44200.t0 VSS 0.16129f
C2299 a_12148_44200.n1 VSS 0.58462f
C2300 a_12148_44200.n2 VSS 2.78788f
C2301 a_12148_44200.n3 VSS 0.68544f
C2302 a_12148_44200.t4 VSS 0.83953f
C2303 a_2148_41600.t5 VSS 0.1448f
C2304 a_2148_41600.t7 VSS 0.59332f
C2305 a_2148_41600.n0 VSS 0.11907f
C2306 a_2148_41600.t2 VSS 0.1243f
C2307 a_2148_41600.t3 VSS 0.1243f
C2308 a_2148_41600.n1 VSS 0.38577f
C2309 a_2148_41600.t0 VSS 0.12712f
C2310 a_2148_41600.t1 VSS 0.12712f
C2311 a_2148_41600.n2 VSS 0.38577f
C2312 a_2148_41600.n3 VSS 1.18313f
C2313 a_2148_41600.n4 VSS 0.35665f
C2314 a_2148_41600.t4 VSS 0.59158f
C2315 a_2148_41600.n5 VSS 0.12082f
C2316 a_2148_41600.n6 VSS 0.13505f
C2317 a_2148_41600.n7 VSS 0.41454f
C2318 a_2148_41600.t6 VSS 0.1448f
C2319 a_11748_41600.t5 VSS 0.14207f
C2320 a_11748_41600.t7 VSS 0.57975f
C2321 a_11748_41600.n0 VSS 0.11619f
C2322 a_11748_41600.t1 VSS 0.12494f
C2323 a_11748_41600.t0 VSS 0.12494f
C2324 a_11748_41600.n1 VSS 0.37643f
C2325 a_11748_41600.t2 VSS 0.12212f
C2326 a_11748_41600.t3 VSS 0.12212f
C2327 a_11748_41600.n2 VSS 0.37643f
C2328 a_11748_41600.n3 VSS 1.15448f
C2329 a_11748_41600.n4 VSS 0.34802f
C2330 a_11748_41600.t4 VSS 0.57804f
C2331 a_11748_41600.n5 VSS 0.1179f
C2332 a_11748_41600.n6 VSS 0.13178f
C2333 a_11748_41600.n7 VSS 0.40451f
C2334 a_11748_41600.t6 VSS 0.14207f
C2335 a_n1000_22678.t0 VSS 0.43066f
C2336 a_n1000_22678.t2 VSS 0.11274f
C2337 a_n1000_22678.n0 VSS 0.61981f
C2338 a_n1000_22678.n1 VSS 1.98011f
C2339 a_n1000_22678.n2 VSS 0.20692f
C2340 a_n1000_22678.t1 VSS 0.43066f
C2341 a_600_22678.t0 VSS 0.47347f
C2342 a_600_22678.t2 VSS 0.12618f
C2343 a_600_22678.n0 VSS 0.69373f
C2344 a_600_22678.n1 VSS 2.21625f
C2345 a_600_22678.n2 VSS 0.23159f
C2346 a_600_22678.t1 VSS 0.47347f
C2347 a_n852_28800.t5 VSS 0.17014f
C2348 a_n852_28800.t7 VSS 0.70902f
C2349 a_n852_28800.n0 VSS 0.12494f
C2350 a_n852_28800.t0 VSS 0.18675f
C2351 a_n852_28800.t1 VSS 0.18675f
C2352 a_n852_28800.n1 VSS 0.46111f
C2353 a_n852_28800.t3 VSS 0.17892f
C2354 a_n852_28800.t2 VSS 0.17892f
C2355 a_n852_28800.n2 VSS 0.46111f
C2356 a_n852_28800.n3 VSS 0.96575f
C2357 a_n852_28800.n4 VSS 0.42664f
C2358 a_n852_28800.t4 VSS 0.70725f
C2359 a_n852_28800.n5 VSS 0.12671f
C2360 a_n852_28800.n6 VSS 0.14146f
C2361 a_n852_28800.n7 VSS 0.49564f
C2362 a_n852_28800.t6 VSS 0.17014f
C2363 a_n852_19400.t4 VSS 0.18447f
C2364 a_n852_19400.t3 VSS 0.18447f
C2365 a_n852_19400.n0 VSS 0.5479f
C2366 a_n852_19400.n1 VSS 0.15638f
C2367 a_n852_19400.t2 VSS 0.77818f
C2368 a_n852_19400.n2 VSS 0.14008f
C2369 a_n852_19400.t6 VSS 0.16971f
C2370 a_n852_19400.t7 VSS 0.16971f
C2371 a_n852_19400.n3 VSS 0.50974f
C2372 a_n852_19400.t0 VSS 0.17261f
C2373 a_n852_19400.t1 VSS 0.17261f
C2374 a_n852_19400.n4 VSS 0.50974f
C2375 a_n852_19400.n5 VSS 1.06759f
C2376 a_n852_19400.n6 VSS 0.47163f
C2377 a_n852_19400.n7 VSS 0.13812f
C2378 a_n852_19400.t5 VSS 0.78013f
C2379 a_n6716_3500.t0 VSS 0.543f
C2380 a_n6716_3500.t1 VSS 1.11245f
C2381 a_n6572_3500.t0 VSS 0.53009f
C2382 a_n6572_3500.t2 VSS 0.11763f
C2383 a_n6572_3500.t3 VSS 0.11768f
C2384 a_n6572_3500.n0 VSS 0.18549f
C2385 a_n6572_3500.t5 VSS 0.36985f
C2386 a_n6572_3500.t4 VSS 0.15622f
C2387 a_n6572_3500.n1 VSS 1.39633f
C2388 a_n6572_3500.n2 VSS 0.64607f
C2389 a_n6572_3500.n3 VSS 0.84861f
C2390 a_n6572_3500.n4 VSS 2.74162f
C2391 a_n6572_3500.n5 VSS 0.25248f
C2392 a_n6572_3500.t1 VSS 0.53018f
C2393 a_n3600_5641.t0 VSS 0.49714f
C2394 a_n3600_5641.t2 VSS 0.11508f
C2395 a_n3600_5641.t3 VSS 0.11503f
C2396 a_n3600_5641.n0 VSS 0.18273f
C2397 a_n3600_5641.t5 VSS 0.3653f
C2398 a_n3600_5641.t4 VSS 0.1539f
C2399 a_n3600_5641.n1 VSS 1.37555f
C2400 a_n3600_5641.n2 VSS 0.55474f
C2401 a_n3600_5641.n3 VSS 1.07214f
C2402 a_n3600_5641.n4 VSS 2.44613f
C2403 a_n3600_5641.n5 VSS 0.28121f
C2404 a_n3600_5641.t1 VSS 0.49705f
C2405 a_n1900_5958.t0 VSS 0.5683f
C2406 a_n1900_5958.t1 VSS 1.16128f
C2407 a_484_3500.t0 VSS 0.57067f
C2408 a_484_3500.t1 VSS 1.16586f
C2409 a_5300_5958.t0 VSS 0.53942f
C2410 a_5300_5958.t1 VSS 1.11788f
C2411 a_n5052_2600.t0 VSS 0.12119f
C2412 a_n5052_2600.t7 VSS 0.04306f
C2413 a_n5052_2600.t6 VSS 0.04303f
C2414 a_n5052_2600.n0 VSS 0.10737f
C2415 a_n5052_2600.t5 VSS 0.04419f
C2416 a_n5052_2600.t4 VSS 0.04422f
C2417 a_n5052_2600.n1 VSS 0.10737f
C2418 a_n5052_2600.n2 VSS 0.98516f
C2419 a_n5052_2600.t2 VSS 0.03011f
C2420 a_n5052_2600.t1 VSS 0.03011f
C2421 a_n5052_2600.n3 VSS 0.09122f
C2422 a_n5052_2600.n4 VSS 0.46257f
C2423 a_n5052_2600.t3 VSS 0.12119f
C2424 a_n5052_n1000.t5 VSS 0.15561f
C2425 a_n5052_n1000.t4 VSS 0.15561f
C2426 a_n5052_n1000.t3 VSS 0.15561f
C2427 a_n5052_n1000.n0 VSS 0.45893f
C2428 a_n5052_n1000.n1 VSS 0.14951f
C2429 a_n5052_n1000.t2 VSS 0.65016f
C2430 a_n5052_n1000.n2 VSS 0.13501f
C2431 a_n5052_n1000.t7 VSS 0.14185f
C2432 a_n5052_n1000.t8 VSS 0.14185f
C2433 a_n5052_n1000.n3 VSS 0.50742f
C2434 a_n5052_n1000.t1 VSS 0.16764f
C2435 a_n5052_n1000.t0 VSS 0.16764f
C2436 a_n5052_n1000.n4 VSS 0.50742f
C2437 a_n5052_n1000.n5 VSS 1.21852f
C2438 a_n5052_n1000.n6 VSS 0.49183f
C2439 a_n5052_n1000.n7 VSS 0.11815f
C2440 a_n5052_n1000.n8 VSS 0.4607f
C2441 a_n5052_n1000.t6 VSS 0.15606f
C2442 a_2148_n500.t3 VSS 0.10871f
C2443 a_2148_n500.t2 VSS 0.10871f
C2444 a_2148_n500.t1 VSS 0.10871f
C2445 a_2148_n500.n0 VSS 0.28658f
C2446 a_2148_n500.n1 VSS 0.09336f
C2447 a_2148_n500.t0 VSS 0.4177f
C2448 a_2148_n500.n2 VSS 0.08431f
C2449 a_2148_n500.t5 VSS 0.08272f
C2450 a_2148_n500.t7 VSS 0.08272f
C2451 a_2148_n500.n3 VSS 0.17591f
C2452 a_2148_n500.t6 VSS 0.08338f
C2453 a_2148_n500.t8 VSS 0.08338f
C2454 a_2148_n500.n4 VSS 0.17591f
C2455 a_2148_n500.n5 VSS 0.81634f
C2456 a_2148_n500.n6 VSS 0.37461f
C2457 a_2148_n500.n7 VSS 0.07378f
C2458 a_2148_n500.n8 VSS 0.28768f
C2459 a_2148_n500.t4 VSS 0.10916f
C2460 a_n10800_n12572.n0 VSS 0.74217f
C2461 a_n10800_n12572.t1 VSS 0.12063f
C2462 a_n10800_n12572.n1 VSS 1.77193f
C2463 a_n10800_n12572.t0 VSS 0.16741f
C2464 a_n7300_n12700.t1 VSS 1.02298f
C2465 a_n7300_n12700.t3 VSS 0.97775f
C2466 a_n7300_n12700.t4 VSS 0.97215f
C2467 a_n7300_n12700.n0 VSS 0.54148f
C2468 a_n7300_n12700.t0 VSS 0.1493f
C2469 a_n7300_n12700.n1 VSS 2.1793f
C2470 a_n7300_n12700.n2 VSS 0.35701f
C2471 a_n7300_n12700.t2 VSS 1.01737f
C2472 a_n6400_n12652.t2 VSS 0.31174f
C2473 a_n6400_n12652.t3 VSS 0.26683f
C2474 a_n6400_n12652.t4 VSS 0.26683f
C2475 a_n6400_n12652.n0 VSS 0.82091f
C2476 a_n6400_n12652.t0 VSS 0.16832f
C2477 a_n6400_n12652.n1 VSS 2.87005f
C2478 a_n6400_n12652.n2 VSS 0.94209f
C2479 a_n6400_n12652.t1 VSS 0.31174f
C2480 a_n10800_n14372.n0 VSS 0.8249f
C2481 a_n10800_n14372.t1 VSS 0.12987f
C2482 a_n10800_n14372.n1 VSS 1.96946f
C2483 a_n10800_n14372.t0 VSS 0.18155f
C2484 a_n7300_n14500.t0 VSS 1.05346f
C2485 a_n7300_n14500.t3 VSS 1.01146f
C2486 a_n7300_n14500.t2 VSS 1.0057f
C2487 a_n7300_n14500.n0 VSS 0.55746f
C2488 a_n7300_n14500.t4 VSS 0.15371f
C2489 a_n7300_n14500.n1 VSS 2.24362f
C2490 a_n7300_n14500.n2 VSS 0.36754f
C2491 a_n7300_n14500.t1 VSS 1.04768f
C2492 a_n6400_n14452.t2 VSS 0.31383f
C2493 a_n6400_n14452.t4 VSS 0.27216f
C2494 a_n6400_n14452.t3 VSS 0.27216f
C2495 a_n6400_n14452.n0 VSS 0.81591f
C2496 a_n6400_n14452.t0 VSS 0.16729f
C2497 a_n6400_n14452.n1 VSS 2.85257f
C2498 a_n6400_n14452.n2 VSS 0.93635f
C2499 a_n6400_n14452.t1 VSS 0.31383f
C2500 a_n10800_n16172.n0 VSS 0.8249f
C2501 a_n10800_n16172.t1 VSS 0.12987f
C2502 a_n10800_n16172.n1 VSS 1.96946f
C2503 a_n10800_n16172.t0 VSS 0.18155f
C2504 a_n7300_n16300.t2 VSS 1.01146f
C2505 a_n7300_n16300.t1 VSS 1.0057f
C2506 a_n7300_n16300.n0 VSS 0.55746f
C2507 a_n7300_n16300.t0 VSS 0.15371f
C2508 a_n7300_n16300.n1 VSS 2.24362f
C2509 a_n7300_n16300.t4 VSS 1.04768f
C2510 a_n7300_n16300.n2 VSS 0.36754f
C2511 a_n7300_n16300.t3 VSS 1.05346f
C2512 a_n6400_n16252.t2 VSS 0.27216f
C2513 a_n6400_n16252.t0 VSS 0.16729f
C2514 a_n6400_n16252.t4 VSS 0.31383f
C2515 a_n6400_n16252.t3 VSS 0.31383f
C2516 a_n6400_n16252.n0 VSS 0.93635f
C2517 a_n6400_n16252.n1 VSS 2.85257f
C2518 a_n6400_n16252.n2 VSS 0.81591f
C2519 a_n6400_n16252.t1 VSS 0.27216f
C2520 a_n10800_n17972.n0 VSS 0.8249f
C2521 a_n10800_n17972.t1 VSS 0.12987f
C2522 a_n10800_n17972.n1 VSS 1.96946f
C2523 a_n10800_n17972.t0 VSS 0.18155f
C2524 a_n7300_n18100.t0 VSS 1.05346f
C2525 a_n7300_n18100.t2 VSS 1.01146f
C2526 a_n7300_n18100.t4 VSS 1.0057f
C2527 a_n7300_n18100.n0 VSS 0.55746f
C2528 a_n7300_n18100.t3 VSS 0.15371f
C2529 a_n7300_n18100.n1 VSS 2.24362f
C2530 a_n7300_n18100.n2 VSS 0.36754f
C2531 a_n7300_n18100.t1 VSS 1.04768f
C2532 a_n6400_n18052.t2 VSS 0.31383f
C2533 a_n6400_n18052.t3 VSS 0.27216f
C2534 a_n6400_n18052.t4 VSS 0.27216f
C2535 a_n6400_n18052.n0 VSS 0.81591f
C2536 a_n6400_n18052.t0 VSS 0.16729f
C2537 a_n6400_n18052.n1 VSS 2.85257f
C2538 a_n6400_n18052.n2 VSS 0.93635f
C2539 a_n6400_n18052.t1 VSS 0.31383f
C2540 a_n10800_n19772.n0 VSS 0.8249f
C2541 a_n10800_n19772.t1 VSS 0.12987f
C2542 a_n10800_n19772.n1 VSS 1.96946f
C2543 a_n10800_n19772.t0 VSS 0.18155f
C2544 a_n7300_n19900.t1 VSS 1.01158f
C2545 a_n7300_n19900.t2 VSS 1.00582f
C2546 a_n7300_n19900.n0 VSS 0.55754f
C2547 a_n7300_n19900.t0 VSS 0.15373f
C2548 a_n7300_n19900.n1 VSS 2.24392f
C2549 a_n7300_n19900.t4 VSS 1.0478f
C2550 a_n7300_n19900.n2 VSS 0.36759f
C2551 a_n7300_n19900.t3 VSS 1.05359f
C2552 a_n6400_n19852.t1 VSS 0.27216f
C2553 a_n6400_n19852.t2 VSS 0.16729f
C2554 a_n6400_n19852.t3 VSS 0.31383f
C2555 a_n6400_n19852.t4 VSS 0.31383f
C2556 a_n6400_n19852.n0 VSS 0.93635f
C2557 a_n6400_n19852.n1 VSS 2.85257f
C2558 a_n6400_n19852.n2 VSS 0.81591f
C2559 a_n6400_n19852.t0 VSS 0.27216f
C2560 a_n10800_n21572.n0 VSS 0.82349f
C2561 a_n10800_n21572.t1 VSS 0.12929f
C2562 a_n10800_n21572.n1 VSS 1.96608f
C2563 a_n10800_n21572.t0 VSS 0.18086f
C2564 a_n7157_n21700.t1 VSS 1.01242f
C2565 a_n7157_n21700.t2 VSS 1.00665f
C2566 a_n7157_n21700.n0 VSS 0.5581f
C2567 a_n7157_n21700.t0 VSS 0.15048f
C2568 a_n7157_n21700.n1 VSS 2.16743f
C2569 a_n7157_n21700.t4 VSS 1.04788f
C2570 a_n7157_n21700.n2 VSS 0.36796f
C2571 a_n7157_n21700.t3 VSS 1.05367f
C2572 a_n6400_n21652.t2 VSS 0.27309f
C2573 a_n6400_n21652.t0 VSS 0.16442f
C2574 a_n6400_n21652.t4 VSS 0.31401f
C2575 a_n6400_n21652.t3 VSS 0.31401f
C2576 a_n6400_n21652.n0 VSS 0.94109f
C2577 a_n6400_n21652.n1 VSS 2.78096f
C2578 a_n6400_n21652.n2 VSS 0.82003f
C2579 a_n6400_n21652.t1 VSS 0.27309f
C2580 a_n10800_n23372.n0 VSS 0.78687f
C2581 a_n10800_n23372.t1 VSS 0.12249f
C2582 a_n10800_n23372.n1 VSS 1.87864f
C2583 a_n10800_n23372.t0 VSS 0.17169f
C2584 a_n7157_n23500.t2 VSS 0.94316f
C2585 a_n7157_n23500.t0 VSS 0.9378f
C2586 a_n7157_n23500.n0 VSS 0.51899f
C2587 a_n7157_n23500.t1 VSS 0.13994f
C2588 a_n7157_n23500.n1 VSS 2.01556f
C2589 a_n7157_n23500.t4 VSS 0.97513f
C2590 a_n7157_n23500.n2 VSS 0.34218f
C2591 a_n7157_n23500.t3 VSS 0.98051f
C2592 a_n6400_n23452.t1 VSS 0.26779f
C2593 a_n6400_n23452.t4 VSS 0.16253f
C2594 a_n6400_n23452.t2 VSS 0.30483f
C2595 a_n6400_n23452.t3 VSS 0.30483f
C2596 a_n6400_n23452.n0 VSS 0.93029f
C2597 a_n6400_n23452.n1 VSS 2.74905f
C2598 a_n6400_n23452.n2 VSS 0.81062f
C2599 a_n6400_n23452.t0 VSS 0.26779f
C2600 VSS.t199 VSS 0.08725f
C2601 VSS.t287 VSS 0.08725f
C2602 VSS.t293 VSS 0.08725f
C2603 VSS.t389 VSS 0.08892f
C2604 VSS.t289 VSS 0.08725f
C2605 VSS.t291 VSS 0.08725f
C2606 VSS.t373 VSS 0.12009f
C2607 VSS.t365 VSS 0.11783f
C2608 VSS.t377 VSS 0.11783f
C2609 VSS.t379 VSS 0.12009f
C2610 VSS.t371 VSS 0.11783f
C2611 VSS.t375 VSS 0.11783f
C2612 VSS.t367 VSS 0.11783f
C2613 VSS.t369 VSS 0.11783f
C2614 VSS.t193 VSS 0.20079f
C2615 VSS.t195 VSS 0.19701f
C2616 VSS.t347 VSS 0.19701f
C2617 VSS.t349 VSS 0.19701f
C2618 VSS.t225 VSS 0.14261f
C2619 VSS.t223 VSS 0.13993f
C2620 VSS.t14 VSS 0.08291f
C2621 VSS.t6 VSS 0.08291f
C2622 VSS.t10 VSS 0.08291f
C2623 VSS.t4 VSS 0.0845f
C2624 VSS.t8 VSS 0.08291f
C2625 VSS.t12 VSS 0.08291f
C2626 VSS.t218 VSS 0.13993f
C2627 VSS.t217 VSS 0.14261f
C2628 VSS.t220 VSS 0.13993f
C2629 VSS.t219 VSS 0.13993f
C2630 VSS.t222 VSS 0.13993f
C2631 VSS.t221 VSS 0.13993f
C2632 VSS.t307 VSS 0.16381f
C2633 VSS.t305 VSS 0.16381f
C2634 VSS.t168 VSS 0.20324f
C2635 VSS.t469 VSS 0.20324f
C2636 VSS.t471 VSS 0.20324f
C2637 VSS.t473 VSS 0.20714f
C2638 VSS.t395 VSS 0.11836f
C2639 VSS.t397 VSS 0.11614f
C2640 VSS.t387 VSS 0.11614f
C2641 VSS.t354 VSS 0.11836f
C2642 VSS.t383 VSS 0.11614f
C2643 VSS.t385 VSS 0.11614f
C2644 VSS.t399 VSS 0.11614f
C2645 VSS.t381 VSS 0.11614f
C2646 VSS.t335 VSS 0.09218f
C2647 VSS.t337 VSS 0.09045f
C2648 VSS.t361 VSS 0.09045f
C2649 VSS.t363 VSS 0.09045f
C2650 VSS.t357 VSS 0.09045f
C2651 VSS.t359 VSS 0.09045f
C2652 VSS.t504 VSS 0.08892f
C2653 VSS.t506 VSS 0.08725f
C2654 VSS.t208 VSS 0.08725f
C2655 VSS.t210 VSS 0.08725f
C2656 VSS.t212 VSS 0.08725f
C2657 VSS.t214 VSS 0.08725f
C2658 VSS.t325 VSS 0.12009f
C2659 VSS.t327 VSS 0.11783f
C2660 VSS.t339 VSS 0.11783f
C2661 VSS.t341 VSS 0.11783f
C2662 VSS.t343 VSS 0.11783f
C2663 VSS.t345 VSS 0.11783f
C2664 VSS.t391 VSS 0.11783f
C2665 VSS.t393 VSS 0.12009f
C2666 VSS.t331 VSS 0.19701f
C2667 VSS.t333 VSS 0.20079f
C2668 VSS.t301 VSS 0.19701f
C2669 VSS.t329 VSS 0.19701f
C2670 VSS.t250 VSS 0.14261f
C2671 VSS.t248 VSS 0.13993f
C2672 VSS.t247 VSS 0.13993f
C2673 VSS.t246 VSS 0.13993f
C2674 VSS.t242 VSS 0.13993f
C2675 VSS.t241 VSS 0.13993f
C2676 VSS.t239 VSS 0.0845f
C2677 VSS.t237 VSS 0.08291f
C2678 VSS.t235 VSS 0.08291f
C2679 VSS.t233 VSS 0.08291f
C2680 VSS.t231 VSS 0.08291f
C2681 VSS.t229 VSS 0.08291f
C2682 VSS.t245 VSS 0.13993f
C2683 VSS.t244 VSS 0.14261f
C2684 VSS.t118 VSS 0.16381f
C2685 VSS.t116 VSS 0.16381f
C2686 VSS.t478 VSS 0.20324f
C2687 VSS.t480 VSS 0.20324f
C2688 VSS.t489 VSS 0.20714f
C2689 VSS.t476 VSS 0.20324f
C2690 VSS.t411 VSS 0.11836f
C2691 VSS.t413 VSS 0.11614f
C2692 VSS.t415 VSS 0.11614f
C2693 VSS.t403 VSS 0.11614f
C2694 VSS.t405 VSS 0.11614f
C2695 VSS.t407 VSS 0.11614f
C2696 VSS.t409 VSS 0.11614f
C2697 VSS.t401 VSS 0.11836f
C2698 VSS.t201 VSS 0.09045f
C2699 VSS.t203 VSS 0.09045f
C2700 VSS.t205 VSS 0.09045f
C2701 VSS.t207 VSS 0.09045f
C2702 VSS.t295 VSS 0.09045f
C2703 VSS.t297 VSS 0.09218f
C2704 VSS.t33 VSS 0.13813f
C2705 VSS.t178 VSS 0.13813f
C2706 VSS.t144 VSS 0.14078f
C2707 VSS.t30 VSS 0.0866f
C2708 VSS.t42 VSS 0.08665f
C2709 VSS.t465 VSS 0.07345f
C2710 VSS.t463 VSS 0.07207f
C2711 VSS.t462 VSS 0.07207f
C2712 VSS.t461 VSS 0.07345f
C2713 VSS.t189 VSS 0.06826f
C2714 VSS.t187 VSS 0.06698f
C2715 VSS.t185 VSS 0.06698f
C2716 VSS.t183 VSS 0.06826f
C2717 VSS.t196 VSS 0.16234f
C2718 VSS.t435 VSS 0.16234f
C2719 VSS.t89 VSS 0.04055f
C2720 VSS.t105 VSS 0.03978f
C2721 VSS.t95 VSS 0.03978f
C2722 VSS.t93 VSS 0.04055f
C2723 VSS.t99 VSS 0.03978f
C2724 VSS.t97 VSS 0.03978f
C2725 VSS.t103 VSS 0.03978f
C2726 VSS.t101 VSS 0.03978f
C2727 VSS.t155 VSS 0.12931f
C2728 VSS.t157 VSS 0.13179f
C2729 VSS.t22 VSS 0.12931f
C2730 VSS.t26 VSS 0.16084f
C2731 VSS.t28 VSS 0.16084f
C2732 VSS.t113 VSS 0.03978f
C2733 VSS.t111 VSS 0.03978f
C2734 VSS.t87 VSS 0.03978f
C2735 VSS.t91 VSS 0.04055f
C2736 VSS.t107 VSS 0.03978f
C2737 VSS.t106 VSS 0.03978f
C2738 VSS.t109 VSS 0.03978f
C2739 VSS.t108 VSS 0.03978f
C2740 VSS.t437 VSS 0.08741f
C2741 VSS.t25 VSS 0.08746f
C2742 VSS.t162 VSS 0.08484f
C2743 VSS.t443 VSS 0.08489f
C2744 VSS.t419 VSS 0.16193f
C2745 VSS.t482 VSS 0.16193f
C2746 VSS.t45 VSS 0.12632f
C2747 VSS.t19 VSS 0.12632f
C2748 VSS.t502 VSS 0.12874f
C2749 VSS.t284 VSS 0.03799f
C2750 VSS.t282 VSS 0.03799f
C2751 VSS.t280 VSS 0.03799f
C2752 VSS.t278 VSS 0.03799f
C2753 VSS.t274 VSS 0.03799f
C2754 VSS.t261 VSS 0.03872f
C2755 VSS.t276 VSS 0.03799f
C2756 VSS.t275 VSS 0.03799f
C2757 VSS.t175 VSS 0.15757f
C2758 VSS.t160 VSS 0.15757f
C2759 VSS.t272 VSS 0.03872f
C2760 VSS.t270 VSS 0.03799f
C2761 VSS.t265 VSS 0.03799f
C2762 VSS.t259 VSS 0.03872f
C2763 VSS.t266 VSS 0.03799f
C2764 VSS.t263 VSS 0.03799f
C2765 VSS.t268 VSS 0.03799f
C2766 VSS.t257 VSS 0.03799f
C2767 VSS.t54 VSS 0.07434f
C2768 VSS.t48 VSS 0.07294f
C2769 VSS.t52 VSS 0.07294f
C2770 VSS.t50 VSS 0.07434f
C2771 VSS.t483 VSS 0.08719f
C2772 VSS.t484 VSS 0.08724f
C2773 VSS.t309 VSS 0.07495f
C2774 VSS.t315 VSS 0.07354f
C2775 VSS.t313 VSS 0.07354f
C2776 VSS.t311 VSS 0.07495f
C2777 VSS.t58 VSS 0.13279f
C2778 VSS.t36 VSS 0.13279f
C2779 VSS.t40 VSS 0.13533f
C2780 VSS.t351 VSS 0.05093f
C2781 VSS.t490 VSS 0.05439f
C2782 VSS.t491 VSS 0.05484f
C2783 VSS.t227 VSS 0.05484f
C2784 VSS.t433 VSS 0.05484f
C2785 VSS.t303 VSS 0.05484f
C2786 VSS.t240 VSS 0.05312f
C2787 VSS.t451 VSS 0.03199f
C2788 VSS.t449 VSS 0.03245f
C2789 VSS.t455 VSS 0.03245f
C2790 VSS.t453 VSS 0.03199f
C2791 VSS.t432 VSS 0.03465f
C2792 VSS.t431 VSS 0.03424f
C2793 VSS.t429 VSS 0.03424f
C2794 VSS.t430 VSS 0.03465f
C2795 VSS.t445 VSS 0.03199f
C2796 VSS.t447 VSS 0.03245f
C2797 VSS.t459 VSS 0.03245f
C2798 VSS.t457 VSS 0.03199f
C2799 VSS.t428 VSS 0.03465f
C2800 VSS.t426 VSS 0.03424f
C2801 VSS.t424 VSS 0.03424f
C2802 VSS.t422 VSS 0.03465f
C2803 VSS.t73 VSS 0.03072f
C2804 VSS.t80 VSS 0.03072f
C2805 VSS.t72 VSS 0.03117f
C2806 VSS.t79 VSS 0.03072f
C2807 VSS.t75 VSS 0.03117f
C2808 VSS.t85 VSS 0.03117f
C2809 VSS.t84 VSS 0.03072f
C2810 VSS.t83 VSS 0.03072f
C2811 VSS.t81 VSS 0.03072f
C2812 VSS.t82 VSS 0.03117f
C2813 VDD.t348 VSS 0.79203f
C2814 VDD.t347 VSS 0.71283f
C2815 VDD.t503 VSS 0.71283f
C2816 VDD.t502 VSS 0.71283f
C2817 VDD.t507 VSS 0.71283f
C2818 VDD.t506 VSS 0.71283f
C2819 VDD.t215 VSS 0.71283f
C2820 VDD.t214 VSS 0.71283f
C2821 VDD.t464 VSS 0.71283f
C2822 VDD.t463 VSS 0.71283f
C2823 VDD.t293 VSS 0.71283f
C2824 VDD.t292 VSS 0.71283f
C2825 VDD.t219 VSS 0.71283f
C2826 VDD.t218 VSS 0.40185f
C2827 VDD.t217 VSS 0.08271f
C2828 VDD.t291 VSS 0.08455f
C2829 VDD.n0 VSS 0.0896f
C2830 VDD.t216 VSS 0.52286f
C2831 VDD.t461 VSS 0.36198f
C2832 VDD.t462 VSS 0.08455f
C2833 VDD.t213 VSS 0.08455f
C2834 VDD.n1 VSS 0.0896f
C2835 VDD.t504 VSS 0.36198f
C2836 VDD.t505 VSS 0.08455f
C2837 VDD.t501 VSS 0.08407f
C2838 VDD.n2 VSS 0.0896f
C2839 VDD.t345 VSS 0.37504f
C2840 VDD.t346 VSS 0.08035f
C2841 VDD.n3 VSS 0.38811f
C2842 VDD.n4 VSS 0.06187f
C2843 VDD.n5 VSS 0.37111f
C2844 VDD.t500 VSS 0.36198f
C2845 VDD.n6 VSS 0.37111f
C2846 VDD.n7 VSS 0.06187f
C2847 VDD.n8 VSS 0.0896f
C2848 VDD.n9 VSS 0.06187f
C2849 VDD.n10 VSS 0.37111f
C2850 VDD.t212 VSS 0.36198f
C2851 VDD.n11 VSS 0.37111f
C2852 VDD.n12 VSS 0.06187f
C2853 VDD.n13 VSS 0.0896f
C2854 VDD.n14 VSS 0.06187f
C2855 VDD.n15 VSS 0.37111f
C2856 VDD.t290 VSS 0.36198f
C2857 VDD.n16 VSS 0.37111f
C2858 VDD.n17 VSS 0.06187f
C2859 VDD.n18 VSS 0.21077f
C2860 VDD.n19 VSS 2.59058f
C2861 VDD.n20 VSS 20.6028f
C2862 VDD.t112 VSS 0.05694f
C2863 VDD.t105 VSS 0.04855f
C2864 VDD.n21 VSS 0.56107f
C2865 VDD.t20 VSS 0.04855f
C2866 VDD.n22 VSS 0.60709f
C2867 VDD.t106 VSS 0.04855f
C2868 VDD.n23 VSS 0.72126f
C2869 VDD.t425 VSS 1.57787f
C2870 VDD.t426 VSS 1.89344f
C2871 VDD.t427 VSS 1.89344f
C2872 VDD.t428 VSS 1.44964f
C2873 VDD.t93 VSS 0.0343f
C2874 VDD.t265 VSS 0.03781f
C2875 VDD.n24 VSS 0.22713f
C2876 VDD.t264 VSS 0.03781f
C2877 VDD.n25 VSS 0.11592f
C2878 VDD.t0 VSS 0.0327f
C2879 VDD.n26 VSS 0.14674f
C2880 VDD.t1 VSS 0.0327f
C2881 VDD.n27 VSS 0.24966f
C2882 VDD.t140 VSS 0.04053f
C2883 VDD.n28 VSS 0.21855f
C2884 VDD.t107 VSS 0.04053f
C2885 VDD.n29 VSS 0.21855f
C2886 VDD.t94 VSS 0.0327f
C2887 VDD.n30 VSS 0.17209f
C2888 VDD.n31 VSS 3.26505f
C2889 VDD.t552 VSS 0.0502f
C2890 VDD.t555 VSS 0.04779f
C2891 VDD.n32 VSS 0.51849f
C2892 VDD.t139 VSS 0.0502f
C2893 VDD.t88 VSS 0.04779f
C2894 VDD.n33 VSS 0.25692f
C2895 VDD.n34 VSS 1.55163f
C2896 VDD.n35 VSS 8.9122f
C2897 VDD.n36 VSS 6.69521f
C2898 VDD.n37 VSS 0.21811f
C2899 VDD.n38 VSS 0.102f
C2900 VDD.n39 VSS 0.11644f
C2901 VDD.n40 VSS 0.11138f
C2902 VDD.t342 VSS 0.51977f
C2903 VDD.n41 VSS 0.11138f
C2904 VDD.n42 VSS 0.11644f
C2905 VDD.n43 VSS 0.1187f
C2906 VDD.n44 VSS 0.11644f
C2907 VDD.n45 VSS 0.11138f
C2908 VDD.n46 VSS 5.19769f
C2909 VDD.n47 VSS 0.31334f
C2910 VDD.t110 VSS 0.14851f
C2911 VDD.n48 VSS 0.11138f
C2912 VDD.n49 VSS 0.11644f
C2913 VDD.n50 VSS 0.1187f
C2914 VDD.n51 VSS 0.11644f
C2915 VDD.n52 VSS 0.11138f
C2916 VDD.t170 VSS 0.59402f
C2917 VDD.n53 VSS 0.11138f
C2918 VDD.n54 VSS 0.11644f
C2919 VDD.n55 VSS 0.1187f
C2920 VDD.n56 VSS 0.11644f
C2921 VDD.n57 VSS 0.11138f
C2922 VDD.t210 VSS 2.22758f
C2923 VDD.t198 VSS 0.44552f
C2924 VDD.n58 VSS 0.50281f
C2925 VDD.n59 VSS 7.10649f
C2926 VDD.n60 VSS 0.11138f
C2927 VDD.n61 VSS 0.11644f
C2928 VDD.n62 VSS 0.09964f
C2929 VDD.n63 VSS 0.11644f
C2930 VDD.n64 VSS 0.11138f
C2931 VDD.n65 VSS 5.68427f
C2932 VDD.n66 VSS 3.98325f
C2933 VDD.t361 VSS 1.48505f
C2934 VDD.t363 VSS 0.59402f
C2935 VDD.t365 VSS 0.59402f
C2936 VDD.t367 VSS 0.59402f
C2937 VDD.t353 VSS 0.59402f
C2938 VDD.t355 VSS 0.59402f
C2939 VDD.t357 VSS 0.59402f
C2940 VDD.t359 VSS 2.22758f
C2941 VDD.t351 VSS 3.48988f
C2942 VDD.t349 VSS 0.51977f
C2943 VDD.n67 VSS 2.15333f
C2944 VDD.n68 VSS 0.11138f
C2945 VDD.n69 VSS 0.11644f
C2946 VDD.n70 VSS 0.32136f
C2947 VDD.n71 VSS 0.1187f
C2948 VDD.n72 VSS 0.1187f
C2949 VDD.n73 VSS 0.11644f
C2950 VDD.n74 VSS 0.11138f
C2951 VDD.n75 VSS 7.42527f
C2952 VDD.n76 VSS 5.19769f
C2953 VDD.n77 VSS 3.76512f
C2954 VDD.n78 VSS 0.31334f
C2955 VDD.n79 VSS 0.31334f
C2956 VDD.n80 VSS 0.498f
C2957 VDD.t200 VSS 0.44552f
C2958 VDD.t196 VSS 0.59402f
C2959 VDD.t202 VSS 0.59402f
C2960 VDD.t204 VSS 0.44552f
C2961 VDD.t547 VSS 0.44552f
C2962 VDD.t546 VSS 0.59402f
C2963 VDD.t134 VSS 0.59402f
C2964 VDD.t133 VSS 0.59402f
C2965 VDD.t487 VSS 0.59402f
C2966 VDD.t486 VSS 0.59402f
C2967 VDD.t104 VSS 0.59402f
C2968 VDD.t103 VSS 0.44552f
C2969 VDD.t447 VSS 0.44552f
C2970 VDD.t437 VSS 0.59402f
C2971 VDD.t449 VSS 0.59402f
C2972 VDD.t451 VSS 0.51977f
C2973 VDD.t416 VSS 0.29701f
C2974 VDD.t453 VSS 0.29701f
C2975 VDD.t414 VSS 0.29701f
C2976 VDD.t455 VSS 0.29701f
C2977 VDD.t484 VSS 0.29701f
C2978 VDD.t457 VSS 0.29701f
C2979 VDD.t482 VSS 0.29701f
C2980 VDD.t459 VSS 0.29701f
C2981 VDD.t480 VSS 0.51977f
C2982 VDD.t423 VSS 0.59402f
C2983 VDD.t421 VSS 0.51977f
C2984 VDD.t208 VSS 0.29701f
C2985 VDD.t419 VSS 0.14851f
C2986 VDD.n81 VSS 0.22276f
C2987 VDD.n82 VSS 0.11138f
C2988 VDD.n83 VSS 0.11644f
C2989 VDD.n84 VSS 0.1187f
C2990 VDD.n85 VSS 0.1187f
C2991 VDD.n86 VSS 0.1187f
C2992 VDD.n87 VSS 0.11644f
C2993 VDD.n88 VSS 0.11138f
C2994 VDD.t194 VSS 0.59402f
C2995 VDD.t192 VSS 1.48505f
C2996 VDD.t156 VSS 2.37609f
C2997 VDD.t191 VSS 1.48505f
C2998 VDD.t190 VSS 0.59402f
C2999 VDD.t189 VSS 0.59402f
C3000 VDD.t188 VSS 0.44552f
C3001 VDD.n89 VSS 0.29701f
C3002 VDD.t187 VSS 0.44552f
C3003 VDD.t186 VSS 0.59402f
C3004 VDD.t185 VSS 0.59402f
C3005 VDD.t184 VSS 1.48505f
C3006 VDD.t158 VSS 2.37609f
C3007 VDD.t182 VSS 1.48505f
C3008 VDD.t206 VSS 0.29701f
C3009 VDD.t108 VSS 0.51977f
C3010 VDD.t91 VSS 0.59402f
C3011 VDD.t89 VSS 0.51977f
C3012 VDD.t431 VSS 0.29701f
C3013 VDD.t550 VSS 0.29701f
C3014 VDD.t429 VSS 0.29701f
C3015 VDD.t548 VSS 0.29701f
C3016 VDD.t433 VSS 0.29701f
C3017 VDD.t137 VSS 0.29701f
C3018 VDD.t435 VSS 0.29701f
C3019 VDD.t135 VSS 0.29701f
C3020 VDD.t439 VSS 0.51977f
C3021 VDD.t441 VSS 0.59402f
C3022 VDD.t443 VSS 0.59402f
C3023 VDD.t445 VSS 0.44552f
C3024 VDD.t407 VSS 0.44552f
C3025 VDD.t410 VSS 0.59402f
C3026 VDD.t409 VSS 0.59402f
C3027 VDD.t408 VSS 0.59402f
C3028 VDD.t413 VSS 0.59402f
C3029 VDD.t412 VSS 0.59402f
C3030 VDD.t411 VSS 0.59402f
C3031 VDD.t418 VSS 0.44552f
C3032 VDD.t172 VSS 0.44552f
C3033 VDD.t174 VSS 0.59402f
C3034 VDD.t166 VSS 0.59402f
C3035 VDD.t164 VSS 0.44552f
C3036 VDD.n90 VSS 0.498f
C3037 VDD.t176 VSS 0.44552f
C3038 VDD.t178 VSS 0.59402f
C3039 VDD.t180 VSS 0.59402f
C3040 VDD.n91 VSS 0.11138f
C3041 VDD.n92 VSS 0.11644f
C3042 VDD.n93 VSS 0.1187f
C3043 VDD.n94 VSS 0.1187f
C3044 VDD.n95 VSS 0.1187f
C3045 VDD.n96 VSS 0.11644f
C3046 VDD.n97 VSS 0.11138f
C3047 VDD.n98 VSS 0.22276f
C3048 VDD.t168 VSS 2.22758f
C3049 VDD.n99 VSS 3.76512f
C3050 VDD.n100 VSS 0.31334f
C3051 VDD.n101 VSS 0.31334f
C3052 VDD.t373 VSS 3.48988f
C3053 VDD.n102 VSS 7.10649f
C3054 VDD.n103 VSS 7.42527f
C3055 VDD.n104 VSS 0.11138f
C3056 VDD.n105 VSS 0.11644f
C3057 VDD.n106 VSS 0.1187f
C3058 VDD.n107 VSS 0.1187f
C3059 VDD.n108 VSS 0.1187f
C3060 VDD.n109 VSS 0.11644f
C3061 VDD.n110 VSS 0.11138f
C3062 VDD.n111 VSS 2.15333f
C3063 VDD.t377 VSS 2.22758f
C3064 VDD.t379 VSS 0.59402f
C3065 VDD.t381 VSS 0.59402f
C3066 VDD.t142 VSS 0.59402f
C3067 VDD.t144 VSS 0.59402f
C3068 VDD.t146 VSS 0.59402f
C3069 VDD.t148 VSS 0.59402f
C3070 VDD.t154 VSS 1.48505f
C3071 VDD.n112 VSS 3.96867f
C3072 VDD.n113 VSS 5.67727f
C3073 VDD.n114 VSS 0.09459f
C3074 VDD.n115 VSS 0.11718f
C3075 VDD.t207 VSS 0.15548f
C3076 VDD.t169 VSS 0.15545f
C3077 VDD.n116 VSS 0.17198f
C3078 VDD.n117 VSS 0.1926f
C3079 VDD.n118 VSS 0.06704f
C3080 VDD.n119 VSS 0.04447f
C3081 VDD.t362 VSS 0.10505f
C3082 VDD.t364 VSS 0.10332f
C3083 VDD.n120 VSS 0.06952f
C3084 VDD.t358 VSS 0.10332f
C3085 VDD.t360 VSS 0.10505f
C3086 VDD.n121 VSS 0.06714f
C3087 VDD.t354 VSS 0.10332f
C3088 VDD.t356 VSS 0.10332f
C3089 VDD.n122 VSS 0.06662f
C3090 VDD.n123 VSS 0.03376f
C3091 VDD.t366 VSS 0.10332f
C3092 VDD.t368 VSS 0.10332f
C3093 VDD.n124 VSS 0.06662f
C3094 VDD.n125 VSS 0.16701f
C3095 VDD.n126 VSS 0.19753f
C3096 VDD.t350 VSS 0.13122f
C3097 VDD.t352 VSS 0.13122f
C3098 VDD.n127 VSS 0.19637f
C3099 VDD.n128 VSS 0.71766f
C3100 VDD.t211 VSS 0.15548f
C3101 VDD.t209 VSS 0.15545f
C3102 VDD.n129 VSS 0.17198f
C3103 VDD.n130 VSS 0.17755f
C3104 VDD.n131 VSS 0.33168f
C3105 VDD.t420 VSS 0.21611f
C3106 VDD.t422 VSS 0.21611f
C3107 VDD.n132 VSS 0.06662f
C3108 VDD.n133 VSS 0.19655f
C3109 VDD.t424 VSS 0.21611f
C3110 VDD.t481 VSS 0.21611f
C3111 VDD.n134 VSS 0.06662f
C3112 VDD.n135 VSS 0.01441f
C3113 VDD.t415 VSS 0.21611f
C3114 VDD.t417 VSS 0.22001f
C3115 VDD.n136 VSS 0.06714f
C3116 VDD.t483 VSS 0.21611f
C3117 VDD.t485 VSS 0.21611f
C3118 VDD.n137 VSS 0.06662f
C3119 VDD.n138 VSS 0.03094f
C3120 VDD.n139 VSS 0.0738f
C3121 VDD.n140 VSS 0.21341f
C3122 VDD.t460 VSS 0.15088f
C3123 VDD.t458 VSS 0.15082f
C3124 VDD.n141 VSS 0.06662f
C3125 VDD.n142 VSS 0.01878f
C3126 VDD.t438 VSS 0.15082f
C3127 VDD.t448 VSS 0.15457f
C3128 VDD.n143 VSS 0.06714f
C3129 VDD.t452 VSS 0.15082f
C3130 VDD.t450 VSS 0.15082f
C3131 VDD.n144 VSS 0.06662f
C3132 VDD.n145 VSS 0.03376f
C3133 VDD.t456 VSS 0.15082f
C3134 VDD.t454 VSS 0.15082f
C3135 VDD.n146 VSS 0.06662f
C3136 VDD.n147 VSS 0.01535f
C3137 VDD.n148 VSS 0.05011f
C3138 VDD.n149 VSS 0.09149f
C3139 VDD.n150 VSS 0.15666f
C3140 VDD.t297 VSS 0.1767f
C3141 VDD.t294 VSS 0.17666f
C3142 VDD.n151 VSS 0.11034f
C3143 VDD.t205 VSS 0.11774f
C3144 VDD.t203 VSS 0.11496f
C3145 VDD.n152 VSS 0.06662f
C3146 VDD.n153 VSS 0.11549f
C3147 VDD.t197 VSS 0.11496f
C3148 VDD.t201 VSS 0.11496f
C3149 VDD.n154 VSS 0.06662f
C3150 VDD.n155 VSS 0.01912f
C3151 VDD.t199 VSS 0.11496f
C3152 VDD.t171 VSS 0.11496f
C3153 VDD.n156 VSS 0.06662f
C3154 VDD.n157 VSS 0.01912f
C3155 VDD.t195 VSS 0.11496f
C3156 VDD.t193 VSS 0.11496f
C3157 VDD.n158 VSS 0.06662f
C3158 VDD.n159 VSS 0.01517f
C3159 VDD.n160 VSS 0.16586f
C3160 VDD.t157 VSS 0.10154f
C3161 VDD.n161 VSS 0.12797f
C3162 VDD.n162 VSS 0.13664f
C3163 VDD.n163 VSS 0.10655f
C3164 VDD.t296 VSS 0.1767f
C3165 VDD.t295 VSS 0.17666f
C3166 VDD.n164 VSS 0.11034f
C3167 VDD.t159 VSS 0.10154f
C3168 VDD.n165 VSS 0.15327f
C3169 VDD.t175 VSS 0.11496f
C3170 VDD.t173 VSS 0.11774f
C3171 VDD.n166 VSS 0.06714f
C3172 VDD.t165 VSS 0.11496f
C3173 VDD.t167 VSS 0.11496f
C3174 VDD.n167 VSS 0.06662f
C3175 VDD.n168 VSS 0.03376f
C3176 VDD.t179 VSS 0.11496f
C3177 VDD.t177 VSS 0.11496f
C3178 VDD.n169 VSS 0.06662f
C3179 VDD.n170 VSS 0.01912f
C3180 VDD.t183 VSS 0.11496f
C3181 VDD.t181 VSS 0.11496f
C3182 VDD.n171 VSS 0.06662f
C3183 VDD.n172 VSS 0.03655f
C3184 VDD.n173 VSS 0.24274f
C3185 VDD.n174 VSS 0.0845f
C3186 VDD.n175 VSS 0.11281f
C3187 VDD.t446 VSS 0.15457f
C3188 VDD.t444 VSS 0.15082f
C3189 VDD.n176 VSS 0.06662f
C3190 VDD.n177 VSS 0.09286f
C3191 VDD.t442 VSS 0.15082f
C3192 VDD.t440 VSS 0.15082f
C3193 VDD.n178 VSS 0.06662f
C3194 VDD.n179 VSS 0.01535f
C3195 VDD.t430 VSS 0.15082f
C3196 VDD.t432 VSS 0.15457f
C3197 VDD.n180 VSS 0.06714f
C3198 VDD.t436 VSS 0.15082f
C3199 VDD.t434 VSS 0.15082f
C3200 VDD.n181 VSS 0.06662f
C3201 VDD.n182 VSS 0.03f
C3202 VDD.n184 VSS 0.2137f
C3203 VDD.t136 VSS 0.21366f
C3204 VDD.t138 VSS 0.20988f
C3205 VDD.n185 VSS 0.06662f
C3206 VDD.n186 VSS 0.08665f
C3207 VDD.t549 VSS 0.20988f
C3208 VDD.t551 VSS 0.20988f
C3209 VDD.n187 VSS 0.06662f
C3210 VDD.n188 VSS 0.01912f
C3211 VDD.t90 VSS 0.20988f
C3212 VDD.t92 VSS 0.20988f
C3213 VDD.n189 VSS 0.06662f
C3214 VDD.n190 VSS 0.01912f
C3215 VDD.t109 VSS 0.20988f
C3216 VDD.t111 VSS 0.20988f
C3217 VDD.n191 VSS 0.06662f
C3218 VDD.n192 VSS 0.19655f
C3219 VDD.n193 VSS 0.3392f
C3220 VDD.t374 VSS 0.13294f
C3221 VDD.t343 VSS 0.13294f
C3222 VDD.n194 VSS 0.19637f
C3223 VDD.n195 VSS 0.38324f
C3224 VDD.n196 VSS 0.19022f
C3225 VDD.t378 VSS 0.10179f
C3226 VDD.t380 VSS 0.10012f
C3227 VDD.n197 VSS 0.06662f
C3228 VDD.n198 VSS 0.16306f
C3229 VDD.t149 VSS 0.10012f
C3230 VDD.t155 VSS 0.10179f
C3231 VDD.n199 VSS 0.06714f
C3232 VDD.t145 VSS 0.10012f
C3233 VDD.t147 VSS 0.10012f
C3234 VDD.n200 VSS 0.06662f
C3235 VDD.n201 VSS 0.03376f
C3236 VDD.t382 VSS 0.10012f
C3237 VDD.t143 VSS 0.10012f
C3238 VDD.n202 VSS 0.06662f
C3239 VDD.n203 VSS 0.16701f
C3240 VDD.n204 VSS 0.24443f
C3241 VDD.n205 VSS 5.32859f
C3242 VDD.n206 VSS 0.23949f
C3243 VDD.n207 VSS 0.07972f
C3244 VDD.n208 VSS 0.11644f
C3245 VDD.n209 VSS 0.11138f
C3246 VDD.t324 VSS 0.74253f
C3247 VDD.n210 VSS 0.11138f
C3248 VDD.n211 VSS 0.11644f
C3249 VDD.n212 VSS 0.1187f
C3250 VDD.n213 VSS 0.11644f
C3251 VDD.n214 VSS 0.11138f
C3252 VDD.t344 VSS 2.8216f
C3253 VDD.n215 VSS 0.31334f
C3254 VDD.t300 VSS 0.44552f
C3255 VDD.n216 VSS 0.11138f
C3256 VDD.n217 VSS 0.11644f
C3257 VDD.n218 VSS 0.1187f
C3258 VDD.n219 VSS 0.11644f
C3259 VDD.n220 VSS 0.11138f
C3260 VDD.t553 VSS 0.74253f
C3261 VDD.n221 VSS 0.11138f
C3262 VDD.n222 VSS 0.11644f
C3263 VDD.n223 VSS 0.1187f
C3264 VDD.n224 VSS 0.11644f
C3265 VDD.n225 VSS 0.11138f
C3266 VDD.t14 VSS 0.44552f
C3267 VDD.n226 VSS 0.50281f
C3268 VDD.t113 VSS 0.74253f
C3269 VDD.n227 VSS 0.11138f
C3270 VDD.n228 VSS 0.11644f
C3271 VDD.n229 VSS 0.09964f
C3272 VDD.n230 VSS 0.11644f
C3273 VDD.n231 VSS 0.11138f
C3274 VDD.n232 VSS 5.68427f
C3275 VDD.n233 VSS 4.28026f
C3276 VDD.n234 VSS 1.78207f
C3277 VDD.t10 VSS 0.59402f
C3278 VDD.t338 VSS 0.59402f
C3279 VDD.t340 VSS 0.59402f
C3280 VDD.t12 VSS 2.8216f
C3281 VDD.t117 VSS 0.59402f
C3282 VDD.t115 VSS 0.59402f
C3283 VDD.t119 VSS 0.59402f
C3284 VDD.t123 VSS 0.59402f
C3285 VDD.t125 VSS 0.59402f
C3286 VDD.t121 VSS 0.59402f
C3287 VDD.t127 VSS 1.48505f
C3288 VDD.n235 VSS 2.57708f
C3289 VDD.t466 VSS 1.48505f
C3290 VDD.t468 VSS 0.59402f
C3291 VDD.t470 VSS 0.59402f
C3292 VDD.t97 VSS 0.59402f
C3293 VDD.t95 VSS 0.59402f
C3294 VDD.t474 VSS 0.59402f
C3295 VDD.t472 VSS 0.59402f
C3296 VDD.t478 VSS 0.74253f
C3297 VDD.n236 VSS 2.97011f
C3298 VDD.n237 VSS 0.11138f
C3299 VDD.n238 VSS 0.11644f
C3300 VDD.n239 VSS 0.32136f
C3301 VDD.n240 VSS 0.1187f
C3302 VDD.n241 VSS 0.1187f
C3303 VDD.n242 VSS 0.11644f
C3304 VDD.n243 VSS 0.11138f
C3305 VDD.n244 VSS 2.97011f
C3306 VDD.t141 VSS 2.8216f
C3307 VDD.t2 VSS 0.59402f
C3308 VDD.t21 VSS 0.59402f
C3309 VDD.t41 VSS 0.59402f
C3310 VDD.n245 VSS 1.78207f
C3311 VDD.t510 VSS 0.59402f
C3312 VDD.t523 VSS 0.59402f
C3313 VDD.t512 VSS 1.48505f
C3314 VDD.n246 VSS 2.87409f
C3315 VDD.n247 VSS 0.31334f
C3316 VDD.n248 VSS 0.31334f
C3317 VDD.n249 VSS 0.498f
C3318 VDD.t23 VSS 2.97011f
C3319 VDD.n250 VSS 3.86114f
C3320 VDD.t276 VSS 1.33655f
C3321 VDD.t556 VSS 0.59402f
C3322 VDD.t262 VSS 0.59402f
C3323 VDD.t8 VSS 1.03954f
C3324 VDD.t514 VSS 1.03954f
C3325 VDD.t517 VSS 0.59402f
C3326 VDD.t519 VSS 0.59402f
C3327 VDD.t16 VSS 0.44552f
C3328 VDD.n251 VSS 0.29701f
C3329 VDD.n252 VSS 0.11138f
C3330 VDD.n253 VSS 0.11644f
C3331 VDD.n254 VSS 0.1187f
C3332 VDD.n255 VSS 0.1187f
C3333 VDD.n256 VSS 0.1187f
C3334 VDD.n257 VSS 0.11644f
C3335 VDD.n258 VSS 0.11138f
C3336 VDD.n259 VSS 4.30666f
C3337 VDD.n260 VSS 7.42527f
C3338 VDD.t313 VSS 0.59402f
C3339 VDD.t309 VSS 0.59402f
C3340 VDD.t315 VSS 1.03954f
C3341 VDD.t18 VSS 1.03954f
C3342 VDD.t42 VSS 0.59402f
C3343 VDD.t44 VSS 0.59402f
C3344 VDD.t568 VSS 1.33655f
C3345 VDD.n261 VSS 3.86114f
C3346 VDD.t99 VSS 2.97011f
C3347 VDD.n262 VSS 0.498f
C3348 VDD.t131 VSS 0.74253f
C3349 VDD.n263 VSS 4.30666f
C3350 VDD.n264 VSS 0.11138f
C3351 VDD.n265 VSS 0.11644f
C3352 VDD.n266 VSS 0.1187f
C3353 VDD.n267 VSS 0.1187f
C3354 VDD.n268 VSS 0.1187f
C3355 VDD.n269 VSS 0.11644f
C3356 VDD.n270 VSS 0.11138f
C3357 VDD.n271 VSS 0.29701f
C3358 VDD.t302 VSS 0.44552f
C3359 VDD.t307 VSS 0.59402f
C3360 VDD.t298 VSS 0.59402f
C3361 VDD.t304 VSS 1.48505f
C3362 VDD.t129 VSS 0.59402f
C3363 VDD.t7 VSS 0.59402f
C3364 VDD.t6 VSS 0.59402f
C3365 VDD.n272 VSS 1.78207f
C3366 VDD.n273 VSS 2.87409f
C3367 VDD.n274 VSS 0.31334f
C3368 VDD.n275 VSS 0.30864f
C3369 VDD.t322 VSS 0.59402f
C3370 VDD.t326 VSS 0.59402f
C3371 VDD.t328 VSS 0.59402f
C3372 VDD.t332 VSS 0.59402f
C3373 VDD.t334 VSS 0.59402f
C3374 VDD.t330 VSS 0.59402f
C3375 VDD.t336 VSS 1.48505f
C3376 VDD.n276 VSS 2.57708f
C3377 VDD.t25 VSS 1.48505f
C3378 VDD.t29 VSS 0.59402f
C3379 VDD.t31 VSS 0.59402f
C3380 VDD.t27 VSS 0.59402f
C3381 VDD.t33 VSS 0.59402f
C3382 VDD.t35 VSS 0.59402f
C3383 VDD.t37 VSS 0.59402f
C3384 VDD.t39 VSS 0.74253f
C3385 VDD.n277 VSS 2.97011f
C3386 VDD.n278 VSS 0.11138f
C3387 VDD.n279 VSS 0.11644f
C3388 VDD.n280 VSS 0.1187f
C3389 VDD.n281 VSS 0.1187f
C3390 VDD.n282 VSS 0.1187f
C3391 VDD.n283 VSS 0.11644f
C3392 VDD.n284 VSS 0.11138f
C3393 VDD.n285 VSS 2.97011f
C3394 VDD.t508 VSS 2.8216f
C3395 VDD.t4 VSS 0.59402f
C3396 VDD.t101 VSS 0.59402f
C3397 VDD.t566 VSS 0.59402f
C3398 VDD.n286 VSS 1.78207f
C3399 VDD.n287 VSS 4.26608f
C3400 VDD.n288 VSS 5.67727f
C3401 VDD.n289 VSS 0.09552f
C3402 VDD.n290 VSS 0.13852f
C3403 VDD.n291 VSS 0.2181f
C3404 VDD.n292 VSS 0.09459f
C3405 VDD.n293 VSS 0.1187f
C3406 VDD.n294 VSS 0.11644f
C3407 VDD.n295 VSS 5.67727f
C3408 VDD.n296 VSS 0.11138f
C3409 VDD.n297 VSS 3.96868f
C3410 VDD.t282 VSS 1.48505f
C3411 VDD.n298 VSS 0.31334f
C3412 VDD.n299 VSS 7.42527f
C3413 VDD.n300 VSS 0.11138f
C3414 VDD.n301 VSS 0.1187f
C3415 VDD.n302 VSS 0.1187f
C3416 VDD.n303 VSS 0.1187f
C3417 VDD.n304 VSS 0.11644f
C3418 VDD.n305 VSS 0.11138f
C3419 VDD.t260 VSS 2.22758f
C3420 VDD.n306 VSS 0.31334f
C3421 VDD.t80 VSS 0.44552f
C3422 VDD.t243 VSS 1.48505f
C3423 VDD.n307 VSS 0.22276f
C3424 VDD.t270 VSS 0.14851f
C3425 VDD.t258 VSS 0.29701f
C3426 VDD.t272 VSS 0.51977f
C3427 VDD.t274 VSS 0.59402f
C3428 VDD.t560 VSS 0.51977f
C3429 VDD.t76 VSS 0.29701f
C3430 VDD.t562 VSS 0.29701f
C3431 VDD.t74 VSS 0.29701f
C3432 VDD.t564 VSS 0.29701f
C3433 VDD.t68 VSS 0.29701f
C3434 VDD.t266 VSS 0.29701f
C3435 VDD.t70 VSS 0.29701f
C3436 VDD.t268 VSS 0.29701f
C3437 VDD.t72 VSS 0.51977f
C3438 VDD.t46 VSS 0.59402f
C3439 VDD.t66 VSS 0.59402f
C3440 VDD.t64 VSS 0.44552f
C3441 VDD.t540 VSS 0.44552f
C3442 VDD.t249 VSS 0.59402f
C3443 VDD.t252 VSS 0.59402f
C3444 VDD.t254 VSS 0.44552f
C3445 VDD.t533 VSS 0.44552f
C3446 VDD.t532 VSS 0.59402f
C3447 VDD.t571 VSS 0.59402f
C3448 VDD.t570 VSS 0.59402f
C3449 VDD.t535 VSS 0.59402f
C3450 VDD.t534 VSS 0.59402f
C3451 VDD.t541 VSS 0.59402f
C3452 VDD.n308 VSS 0.11138f
C3453 VDD.n309 VSS 0.11138f
C3454 VDD.n310 VSS 0.11644f
C3455 VDD.n311 VSS 0.1187f
C3456 VDD.n312 VSS 0.1187f
C3457 VDD.n313 VSS 0.1187f
C3458 VDD.n314 VSS 0.1187f
C3459 VDD.n315 VSS 0.1187f
C3460 VDD.n316 VSS 0.11644f
C3461 VDD.n317 VSS 0.11138f
C3462 VDD.t160 VSS 2.37609f
C3463 VDD.t242 VSS 1.48505f
C3464 VDD.t241 VSS 0.59402f
C3465 VDD.t240 VSS 0.59402f
C3466 VDD.t85 VSS 0.44552f
C3467 VDD.n318 VSS 0.29701f
C3468 VDD.t84 VSS 0.44552f
C3469 VDD.t239 VSS 0.59402f
C3470 VDD.t238 VSS 0.59402f
C3471 VDD.t237 VSS 1.48505f
C3472 VDD.t162 VSS 2.37609f
C3473 VDD.t235 VSS 1.48505f
C3474 VDD.t222 VSS 2.22758f
C3475 VDD.n319 VSS 0.11138f
C3476 VDD.n320 VSS 0.1187f
C3477 VDD.n321 VSS 0.1187f
C3478 VDD.n322 VSS 0.1187f
C3479 VDD.n323 VSS 0.1187f
C3480 VDD.n324 VSS 0.11644f
C3481 VDD.n325 VSS 0.11138f
C3482 VDD.n326 VSS 5.19769f
C3483 VDD.n327 VSS 3.76512f
C3484 VDD.n328 VSS 0.31334f
C3485 VDD.n329 VSS 0.50282f
C3486 VDD.t278 VSS 2.22758f
C3487 VDD.n330 VSS 0.11138f
C3488 VDD.n331 VSS 0.1187f
C3489 VDD.n332 VSS 0.32136f
C3490 VDD.t280 VSS 0.59402f
C3491 VDD.t399 VSS 0.59402f
C3492 VDD.t401 VSS 0.59402f
C3493 VDD.t403 VSS 0.59402f
C3494 VDD.t405 VSS 0.59402f
C3495 VDD.t150 VSS 0.59402f
C3496 VDD.t152 VSS 1.48505f
C3497 VDD.n333 VSS 3.98324f
C3498 VDD.n334 VSS 5.68427f
C3499 VDD.n335 VSS 0.09964f
C3500 VDD.n336 VSS 0.11644f
C3501 VDD.n337 VSS 0.11644f
C3502 VDD.n338 VSS 0.11138f
C3503 VDD.n339 VSS 2.15333f
C3504 VDD.t397 VSS 0.51977f
C3505 VDD.t395 VSS 3.48988f
C3506 VDD.n340 VSS 7.10649f
C3507 VDD.n341 VSS 7.42527f
C3508 VDD.n342 VSS 0.11138f
C3509 VDD.n343 VSS 0.11644f
C3510 VDD.n344 VSS 0.11644f
C3511 VDD.n345 VSS 0.11644f
C3512 VDD.n346 VSS 0.11138f
C3513 VDD.n347 VSS 0.22276f
C3514 VDD.t538 VSS 0.14851f
C3515 VDD.t256 VSS 0.29701f
C3516 VDD.t536 VSS 0.51977f
C3517 VDD.t544 VSS 0.59402f
C3518 VDD.t542 VSS 0.51977f
C3519 VDD.t52 VSS 0.29701f
C3520 VDD.t490 VSS 0.29701f
C3521 VDD.t56 VSS 0.29701f
C3522 VDD.t488 VSS 0.29701f
C3523 VDD.t54 VSS 0.29701f
C3524 VDD.t494 VSS 0.29701f
C3525 VDD.t50 VSS 0.29701f
C3526 VDD.t492 VSS 0.29701f
C3527 VDD.t58 VSS 0.51977f
C3528 VDD.t60 VSS 0.59402f
C3529 VDD.t62 VSS 0.59402f
C3530 VDD.t48 VSS 0.44552f
C3531 VDD.t376 VSS 0.44552f
C3532 VDD.t375 VSS 0.59402f
C3533 VDD.t370 VSS 0.59402f
C3534 VDD.t369 VSS 0.59402f
C3535 VDD.t372 VSS 0.59402f
C3536 VDD.t371 VSS 0.59402f
C3537 VDD.t559 VSS 0.59402f
C3538 VDD.t558 VSS 0.44552f
C3539 VDD.t220 VSS 0.44552f
C3540 VDD.t229 VSS 0.59402f
C3541 VDD.t231 VSS 0.59402f
C3542 VDD.t78 VSS 0.44552f
C3543 VDD.n348 VSS 0.498f
C3544 VDD.t82 VSS 0.44552f
C3545 VDD.t227 VSS 0.59402f
C3546 VDD.t224 VSS 0.59402f
C3547 VDD.n349 VSS 0.11138f
C3548 VDD.n350 VSS 0.11644f
C3549 VDD.n351 VSS 0.11644f
C3550 VDD.n352 VSS 0.11644f
C3551 VDD.n353 VSS 0.11138f
C3552 VDD.t245 VSS 0.59402f
C3553 VDD.t247 VSS 0.59402f
C3554 VDD.t86 VSS 0.44552f
C3555 VDD.n354 VSS 0.498f
C3556 VDD.n355 VSS 0.31334f
C3557 VDD.n356 VSS 0.31334f
C3558 VDD.n357 VSS 3.76512f
C3559 VDD.n358 VSS 5.19769f
C3560 VDD.n359 VSS 0.11138f
C3561 VDD.n360 VSS 0.11644f
C3562 VDD.n361 VSS 0.11644f
C3563 VDD.n362 VSS 0.11644f
C3564 VDD.n363 VSS 0.11138f
C3565 VDD.n364 VSS 7.10649f
C3566 VDD.t393 VSS 3.48988f
C3567 VDD.t391 VSS 0.51977f
C3568 VDD.n365 VSS 2.15333f
C3569 VDD.t389 VSS 2.22758f
C3570 VDD.t387 VSS 0.59402f
C3571 VDD.t385 VSS 0.59402f
C3572 VDD.t383 VSS 0.59402f
C3573 VDD.t288 VSS 0.59402f
C3574 VDD.t286 VSS 0.59402f
C3575 VDD.t284 VSS 0.59402f
C3576 VDD.n366 VSS 0.11138f
C3577 VDD.n367 VSS 0.11644f
C3578 VDD.n368 VSS 0.102f
C3579 VDD.n369 VSS 0.11718f
C3580 VDD.t261 VSS 0.15545f
C3581 VDD.t259 VSS 0.15548f
C3582 VDD.n370 VSS 0.17198f
C3583 VDD.n371 VSS 0.1926f
C3584 VDD.n372 VSS 0.06704f
C3585 VDD.t77 VSS 0.15457f
C3586 VDD.t75 VSS 0.15082f
C3587 VDD.n373 VSS 0.06714f
C3588 VDD.t69 VSS 0.15082f
C3589 VDD.t71 VSS 0.15082f
C3590 VDD.n374 VSS 0.06662f
C3591 VDD.n375 VSS 0.03f
C3592 VDD.n376 VSS 0.04447f
C3593 VDD.t49 VSS 0.15457f
C3594 VDD.t63 VSS 0.15082f
C3595 VDD.n377 VSS 0.06714f
C3596 VDD.t61 VSS 0.15082f
C3597 VDD.t59 VSS 0.15082f
C3598 VDD.n378 VSS 0.06662f
C3599 VDD.n379 VSS 0.03376f
C3600 VDD.t51 VSS 0.15082f
C3601 VDD.t55 VSS 0.15082f
C3602 VDD.n380 VSS 0.06662f
C3603 VDD.n381 VSS 0.01535f
C3604 VDD.t493 VSS 0.22001f
C3605 VDD.t495 VSS 0.21611f
C3606 VDD.n382 VSS 0.06714f
C3607 VDD.t489 VSS 0.21611f
C3608 VDD.t491 VSS 0.21611f
C3609 VDD.n383 VSS 0.06662f
C3610 VDD.n384 VSS 0.03094f
C3611 VDD.t257 VSS 0.15545f
C3612 VDD.t223 VSS 0.15548f
C3613 VDD.n385 VSS 0.17198f
C3614 VDD.n386 VSS 0.17755f
C3615 VDD.t279 VSS 0.10505f
C3616 VDD.t281 VSS 0.10332f
C3617 VDD.n387 VSS 0.06714f
C3618 VDD.t400 VSS 0.10332f
C3619 VDD.t402 VSS 0.10332f
C3620 VDD.n388 VSS 0.06662f
C3621 VDD.n389 VSS 0.03376f
C3622 VDD.t404 VSS 0.10332f
C3623 VDD.t406 VSS 0.10332f
C3624 VDD.n390 VSS 0.06662f
C3625 VDD.n391 VSS 0.16701f
C3626 VDD.t151 VSS 0.10332f
C3627 VDD.t153 VSS 0.10505f
C3628 VDD.n392 VSS 0.06952f
C3629 VDD.n393 VSS 0.19753f
C3630 VDD.t396 VSS 0.13122f
C3631 VDD.t398 VSS 0.13122f
C3632 VDD.n394 VSS 0.19637f
C3633 VDD.n395 VSS 0.71766f
C3634 VDD.n396 VSS 0.33168f
C3635 VDD.t537 VSS 0.21611f
C3636 VDD.t539 VSS 0.21611f
C3637 VDD.n397 VSS 0.06662f
C3638 VDD.n398 VSS 0.19655f
C3639 VDD.t543 VSS 0.21611f
C3640 VDD.t545 VSS 0.21611f
C3641 VDD.n399 VSS 0.06662f
C3642 VDD.n400 VSS 0.01441f
C3643 VDD.n401 VSS 0.0738f
C3644 VDD.n402 VSS 0.21341f
C3645 VDD.t57 VSS 0.15082f
C3646 VDD.t53 VSS 0.15088f
C3647 VDD.n403 VSS 0.06662f
C3648 VDD.n404 VSS 0.01878f
C3649 VDD.n405 VSS 0.05011f
C3650 VDD.n406 VSS 0.09149f
C3651 VDD.n407 VSS 0.15666f
C3652 VDD.t83 VSS 0.17666f
C3653 VDD.t79 VSS 0.1767f
C3654 VDD.n408 VSS 0.11034f
C3655 VDD.t236 VSS 0.11496f
C3656 VDD.t225 VSS 0.11496f
C3657 VDD.n409 VSS 0.06662f
C3658 VDD.t230 VSS 0.11496f
C3659 VDD.t221 VSS 0.11774f
C3660 VDD.n410 VSS 0.06662f
C3661 VDD.n411 VSS 0.11549f
C3662 VDD.t233 VSS 0.11496f
C3663 VDD.t232 VSS 0.11496f
C3664 VDD.n412 VSS 0.06662f
C3665 VDD.n413 VSS 0.01912f
C3666 VDD.t228 VSS 0.11496f
C3667 VDD.t234 VSS 0.11496f
C3668 VDD.n414 VSS 0.06662f
C3669 VDD.n415 VSS 0.01912f
C3670 VDD.n416 VSS 0.01517f
C3671 VDD.n417 VSS 0.16586f
C3672 VDD.t163 VSS 0.10154f
C3673 VDD.n418 VSS 0.12797f
C3674 VDD.n419 VSS 0.13664f
C3675 VDD.n420 VSS 0.10655f
C3676 VDD.t81 VSS 0.17666f
C3677 VDD.t87 VSS 0.1767f
C3678 VDD.n421 VSS 0.11034f
C3679 VDD.t255 VSS 0.11774f
C3680 VDD.t253 VSS 0.11496f
C3681 VDD.n422 VSS 0.06714f
C3682 VDD.t250 VSS 0.11496f
C3683 VDD.t251 VSS 0.11496f
C3684 VDD.n423 VSS 0.06662f
C3685 VDD.n424 VSS 0.03376f
C3686 VDD.t226 VSS 0.11496f
C3687 VDD.t248 VSS 0.11496f
C3688 VDD.n425 VSS 0.06662f
C3689 VDD.n426 VSS 0.01912f
C3690 VDD.t246 VSS 0.11496f
C3691 VDD.t244 VSS 0.11496f
C3692 VDD.n427 VSS 0.06662f
C3693 VDD.t161 VSS 0.10154f
C3694 VDD.n428 VSS 0.15327f
C3695 VDD.n429 VSS 0.03655f
C3696 VDD.n430 VSS 0.24274f
C3697 VDD.n431 VSS 0.0845f
C3698 VDD.n432 VSS 0.11281f
C3699 VDD.t67 VSS 0.15082f
C3700 VDD.t65 VSS 0.15457f
C3701 VDD.n433 VSS 0.06662f
C3702 VDD.n434 VSS 0.09286f
C3703 VDD.t73 VSS 0.15082f
C3704 VDD.t47 VSS 0.15082f
C3705 VDD.n435 VSS 0.06662f
C3706 VDD.n436 VSS 0.01535f
C3707 VDD.n438 VSS 0.2137f
C3708 VDD.t267 VSS 0.20988f
C3709 VDD.t269 VSS 0.21366f
C3710 VDD.n439 VSS 0.06662f
C3711 VDD.n440 VSS 0.08665f
C3712 VDD.t563 VSS 0.20988f
C3713 VDD.t565 VSS 0.20988f
C3714 VDD.n441 VSS 0.06662f
C3715 VDD.n442 VSS 0.01912f
C3716 VDD.t275 VSS 0.20988f
C3717 VDD.t561 VSS 0.20988f
C3718 VDD.n443 VSS 0.06662f
C3719 VDD.n444 VSS 0.01912f
C3720 VDD.t271 VSS 0.20988f
C3721 VDD.t273 VSS 0.20988f
C3722 VDD.n445 VSS 0.06662f
C3723 VDD.n446 VSS 0.19655f
C3724 VDD.n447 VSS 0.3392f
C3725 VDD.t392 VSS 0.13294f
C3726 VDD.t394 VSS 0.13294f
C3727 VDD.n448 VSS 0.19637f
C3728 VDD.n449 VSS 0.38324f
C3729 VDD.n450 VSS 0.19022f
C3730 VDD.t283 VSS 0.10179f
C3731 VDD.t285 VSS 0.10012f
C3732 VDD.n451 VSS 0.06714f
C3733 VDD.t287 VSS 0.10012f
C3734 VDD.t289 VSS 0.10012f
C3735 VDD.n452 VSS 0.06662f
C3736 VDD.n453 VSS 0.03376f
C3737 VDD.t384 VSS 0.10012f
C3738 VDD.t386 VSS 0.10012f
C3739 VDD.n454 VSS 0.06662f
C3740 VDD.t388 VSS 0.10012f
C3741 VDD.t390 VSS 0.10179f
C3742 VDD.n455 VSS 0.06662f
C3743 VDD.n456 VSS 0.16306f
C3744 VDD.n457 VSS 0.16701f
C3745 VDD.n458 VSS 0.24443f
C3746 VDD.n459 VSS 5.25434f
C3747 VDD.n460 VSS 26.3698f
C3748 VDD.n461 VSS 0.06972f
C3749 VDD.t496 VSS 0.1748f
C3750 VDD.t497 VSS 0.1748f
C3751 VDD.n462 VSS 0.10497f
C3752 VDD.t43 VSS 0.13919f
C3753 VDD.t19 VSS 0.14162f
C3754 VDD.n463 VSS 0.06714f
C3755 VDD.t569 VSS 0.14162f
C3756 VDD.t45 VSS 0.13919f
C3757 VDD.n464 VSS 0.06662f
C3758 VDD.n465 VSS 0.03352f
C3759 VDD.n466 VSS 0.17198f
C3760 VDD.t317 VSS 0.08229f
C3761 VDD.t305 VSS 0.08229f
C3762 VDD.n467 VSS 0.06714f
C3763 VDD.t303 VSS 0.08229f
C3764 VDD.t318 VSS 0.08229f
C3765 VDD.n468 VSS 0.06662f
C3766 VDD.n469 VSS 0.03376f
C3767 VDD.t319 VSS 0.08229f
C3768 VDD.t301 VSS 0.08229f
C3769 VDD.n470 VSS 0.06662f
C3770 VDD.n471 VSS 0.01912f
C3771 VDD.t321 VSS 0.08362f
C3772 VDD.t320 VSS 0.08229f
C3773 VDD.n472 VSS 0.06662f
C3774 VDD.n473 VSS 0.01912f
C3775 VDD.n474 VSS 0.05896f
C3776 VDD.n475 VSS 0.17205f
C3777 VDD.n476 VSS 0.10308f
C3778 VDD.t24 VSS 0.1752f
C3779 VDD.t554 VSS 0.17523f
C3780 VDD.n477 VSS 0.1215f
C3781 VDD.t9 VSS 0.14466f
C3782 VDD.t263 VSS 0.14218f
C3783 VDD.n478 VSS 0.06714f
C3784 VDD.t557 VSS 0.14218f
C3785 VDD.t277 VSS 0.14466f
C3786 VDD.n479 VSS 0.06662f
C3787 VDD.n480 VSS 0.06868f
C3788 VDD.n481 VSS 0.14453f
C3789 VDD.t15 VSS 0.17371f
C3790 VDD.t17 VSS 0.17371f
C3791 VDD.n482 VSS 0.10497f
C3792 VDD.t341 VSS 0.15101f
C3793 VDD.t13 VSS 0.15365f
C3794 VDD.n483 VSS 0.06714f
C3795 VDD.t11 VSS 0.15365f
C3796 VDD.t339 VSS 0.15101f
C3797 VDD.n484 VSS 0.06662f
C3798 VDD.n485 VSS 0.11211f
C3799 VDD.n486 VSS 0.31545f
C3800 VDD.t469 VSS 0.08494f
C3801 VDD.t467 VSS 0.08632f
C3802 VDD.n487 VSS 0.06714f
C3803 VDD.t476 VSS 0.08494f
C3804 VDD.t471 VSS 0.08494f
C3805 VDD.n488 VSS 0.06662f
C3806 VDD.n489 VSS 0.03376f
C3807 VDD.t475 VSS 0.08494f
C3808 VDD.t477 VSS 0.08494f
C3809 VDD.n490 VSS 0.06662f
C3810 VDD.n491 VSS 0.01912f
C3811 VDD.t479 VSS 0.08632f
C3812 VDD.t473 VSS 0.08494f
C3813 VDD.n492 VSS 0.06662f
C3814 VDD.n493 VSS 0.1932f
C3815 VDD.t96 VSS 0.17369f
C3816 VDD.t98 VSS 0.17373f
C3817 VDD.n494 VSS 0.0822f
C3818 VDD.n495 VSS 0.23846f
C3819 VDD.n496 VSS 0.12941f
C3820 VDD.n497 VSS 0.21378f
C3821 VDD.t128 VSS 0.08113f
C3822 VDD.t122 VSS 0.07985f
C3823 VDD.n498 VSS 0.06662f
C3824 VDD.n499 VSS 0.16499f
C3825 VDD.t118 VSS 0.07985f
C3826 VDD.t114 VSS 0.08113f
C3827 VDD.n500 VSS 0.06714f
C3828 VDD.t120 VSS 0.07985f
C3829 VDD.t116 VSS 0.07985f
C3830 VDD.n501 VSS 0.06662f
C3831 VDD.n502 VSS 0.03376f
C3832 VDD.t126 VSS 0.07985f
C3833 VDD.t124 VSS 0.07985f
C3834 VDD.n503 VSS 0.06662f
C3835 VDD.n504 VSS 0.01535f
C3836 VDD.n505 VSS 0.16111f
C3837 VDD.n506 VSS 0.2025f
C3838 VDD.t3 VSS 0.17521f
C3839 VDD.t22 VSS 0.17521f
C3840 VDD.n507 VSS 0.22301f
C3841 VDD.n508 VSS 0.28239f
C3842 VDD.n509 VSS 0.17105f
C3843 VDD.t526 VSS 0.08527f
C3844 VDD.t516 VSS 0.08527f
C3845 VDD.n510 VSS 0.06714f
C3846 VDD.t528 VSS 0.08527f
C3847 VDD.t527 VSS 0.08527f
C3848 VDD.n511 VSS 0.06662f
C3849 VDD.n512 VSS 0.03376f
C3850 VDD.t530 VSS 0.08527f
C3851 VDD.t529 VSS 0.08527f
C3852 VDD.n513 VSS 0.06662f
C3853 VDD.n514 VSS 0.01912f
C3854 VDD.t513 VSS 0.08666f
C3855 VDD.t531 VSS 0.08527f
C3856 VDD.n515 VSS 0.06662f
C3857 VDD.n516 VSS 0.01912f
C3858 VDD.n517 VSS 0.15589f
C3859 VDD.n518 VSS 0.17205f
C3860 VDD.n519 VSS 0.13328f
C3861 VDD.t525 VSS 0.08666f
C3862 VDD.t524 VSS 0.08527f
C3863 VDD.n520 VSS 0.06662f
C3864 VDD.n521 VSS 0.02977f
C3865 VDD.t511 VSS 0.08527f
C3866 VDD.t522 VSS 0.08527f
C3867 VDD.n522 VSS 0.06662f
C3868 VDD.n523 VSS 0.01912f
C3869 VDD.t521 VSS 0.08527f
C3870 VDD.t520 VSS 0.08527f
C3871 VDD.n524 VSS 0.06662f
C3872 VDD.n525 VSS 0.01912f
C3873 VDD.t518 VSS 0.08527f
C3874 VDD.t515 VSS 0.08527f
C3875 VDD.n526 VSS 0.06662f
C3876 VDD.n527 VSS 0.08948f
C3877 VDD.n528 VSS 0.09575f
C3878 VDD.n529 VSS 0.21406f
C3879 VDD.t132 VSS 0.17043f
C3880 VDD.t100 VSS 0.17046f
C3881 VDD.n530 VSS 0.18009f
C3882 VDD.n531 VSS 0.32269f
C3883 VDD.n532 VSS 0.10872f
C3884 VDD.t299 VSS 0.08229f
C3885 VDD.t306 VSS 0.08229f
C3886 VDD.n533 VSS 0.06714f
C3887 VDD.t311 VSS 0.08229f
C3888 VDD.t308 VSS 0.08229f
C3889 VDD.n534 VSS 0.06662f
C3890 VDD.n535 VSS 0.03376f
C3891 VDD.t314 VSS 0.08229f
C3892 VDD.t312 VSS 0.08229f
C3893 VDD.n536 VSS 0.06662f
C3894 VDD.n537 VSS 0.01912f
C3895 VDD.t316 VSS 0.08362f
C3896 VDD.t310 VSS 0.08229f
C3897 VDD.n538 VSS 0.06662f
C3898 VDD.n539 VSS 0.01912f
C3899 VDD.n540 VSS 0.11723f
C3900 VDD.n541 VSS 0.13283f
C3901 VDD.n542 VSS 0.08427f
C3902 VDD.t465 VSS 0.17044f
C3903 VDD.t130 VSS 0.17044f
C3904 VDD.n543 VSS 0.22301f
C3905 VDD.n544 VSS 0.32002f
C3906 VDD.n545 VSS 0.22131f
C3907 VDD.t40 VSS 0.08721f
C3908 VDD.t38 VSS 0.08582f
C3909 VDD.n546 VSS 0.06662f
C3910 VDD.n547 VSS 0.16499f
C3911 VDD.t30 VSS 0.08582f
C3912 VDD.t26 VSS 0.08721f
C3913 VDD.n548 VSS 0.06714f
C3914 VDD.t28 VSS 0.08582f
C3915 VDD.t32 VSS 0.08582f
C3916 VDD.n549 VSS 0.06662f
C3917 VDD.n550 VSS 0.03376f
C3918 VDD.t36 VSS 0.08582f
C3919 VDD.t34 VSS 0.08582f
C3920 VDD.n551 VSS 0.06662f
C3921 VDD.n552 VSS 0.01535f
C3922 VDD.n553 VSS 0.16111f
C3923 VDD.n554 VSS 0.20626f
C3924 VDD.n555 VSS 0.20704f
C3925 VDD.t323 VSS 0.08641f
C3926 VDD.t325 VSS 0.08782f
C3927 VDD.n556 VSS 0.06714f
C3928 VDD.t329 VSS 0.08641f
C3929 VDD.t327 VSS 0.08641f
C3930 VDD.n557 VSS 0.06662f
C3931 VDD.n558 VSS 0.03376f
C3932 VDD.t335 VSS 0.08641f
C3933 VDD.t333 VSS 0.08641f
C3934 VDD.n559 VSS 0.06662f
C3935 VDD.n560 VSS 0.01912f
C3936 VDD.t337 VSS 0.08782f
C3937 VDD.t331 VSS 0.08641f
C3938 VDD.n561 VSS 0.06662f
C3939 VDD.n562 VSS 0.1932f
C3940 VDD.t498 VSS 0.17479f
C3941 VDD.t499 VSS 0.17482f
C3942 VDD.n563 VSS 0.0822f
C3943 VDD.n564 VSS 0.23846f
C3944 VDD.n565 VSS 0.13317f
C3945 VDD.t102 VSS 0.14566f
C3946 VDD.t567 VSS 0.1482f
C3947 VDD.n566 VSS 0.06714f
C3948 VDD.t509 VSS 0.1482f
C3949 VDD.t5 VSS 0.14566f
C3950 VDD.n567 VSS 0.06662f
C3951 VDD.n568 VSS 0.10218f
C3952 VDD.n569 VSS 0.19027f
C3953 VDD.n570 VSS 18.2528f
C3954 VDD.n571 VSS 21.426f
C3955 VDD.n572 VSS 30.5495f
C3956 VDD.n573 VSS 21.9237f
C3957 E_CAPTURE_CLKB.n0 VSS 0.04638f
C3958 E_CAPTURE_CLKB.n1 VSS 0.04638f
C3959 E_CAPTURE_CLKB.n2 VSS 0.04638f
C3960 E_CAPTURE_CLKB.n3 VSS 0.04638f
C3961 E_CAPTURE_CLKB.n4 VSS 0.13499f
C3962 E_CAPTURE_CLKB.n5 VSS 0.06672f
C3963 E_CAPTURE_CLKB.n6 VSS 0.07152f
C3964 E_CAPTURE_CLKB.n7 VSS 0.07152f
C3965 E_CAPTURE_CLKB.n8 VSS 0.07152f
C3966 E_CAPTURE_CLKB.n9 VSS 0.07152f
C3967 E_CAPTURE_CLKB.n10 VSS 0.07152f
C3968 E_CAPTURE_CLKB.n11 VSS 0.07152f
C3969 E_CAPTURE_CLKB.n12 VSS 0.06759f
C3970 E_CAPTURE_CLKB.n13 VSS 0.29449f
C3971 E_CAPTURE_CLKB.n14 VSS 0.04638f
C3972 E_CAPTURE_CLKB.n15 VSS 0.07152f
C3973 E_CAPTURE_CLKB.n16 VSS 0.13499f
C3974 E_CAPTURE_CLKB.n17 VSS 0.06672f
C3975 E_CAPTURE_CLKB.n18 VSS 0.07152f
C3976 E_CAPTURE_CLKB.n19 VSS 0.07152f
C3977 E_CAPTURE_CLKB.n20 VSS 0.07152f
C3978 E_CAPTURE_CLKB.n21 VSS 0.04638f
C3979 E_CAPTURE_CLKB.n22 VSS 0.04638f
C3980 E_CAPTURE_CLKB.n23 VSS 0.04638f
C3981 E_CAPTURE_CLKB.n24 VSS 0.07152f
C3982 E_CAPTURE_CLKB.n25 VSS 0.07152f
C3983 E_CAPTURE_CLKB.n26 VSS 0.06759f
C3984 E_CAPTURE_CLKB.n27 VSS 0.11864f
C3985 E_CAPTURE_CLKB.n28 VSS 3.28491f
C3986 O_CAPTURE_CLKB.n0 VSS 0.04837f
C3987 O_CAPTURE_CLKB.n1 VSS 0.04837f
C3988 O_CAPTURE_CLKB.n2 VSS 0.04837f
C3989 O_CAPTURE_CLKB.n3 VSS 0.04837f
C3990 O_CAPTURE_CLKB.n4 VSS 0.14078f
C3991 O_CAPTURE_CLKB.n5 VSS 0.06959f
C3992 O_CAPTURE_CLKB.n6 VSS 0.07459f
C3993 O_CAPTURE_CLKB.n7 VSS 0.07459f
C3994 O_CAPTURE_CLKB.n8 VSS 0.07459f
C3995 O_CAPTURE_CLKB.n9 VSS 0.07459f
C3996 O_CAPTURE_CLKB.n10 VSS 0.07459f
C3997 O_CAPTURE_CLKB.n11 VSS 0.07459f
C3998 O_CAPTURE_CLKB.n12 VSS 0.0705f
C3999 O_CAPTURE_CLKB.n13 VSS 0.30713f
C4000 O_CAPTURE_CLKB.n14 VSS 0.04837f
C4001 O_CAPTURE_CLKB.n15 VSS 0.07459f
C4002 O_CAPTURE_CLKB.n16 VSS 0.14078f
C4003 O_CAPTURE_CLKB.n17 VSS 0.06959f
C4004 O_CAPTURE_CLKB.n18 VSS 0.07459f
C4005 O_CAPTURE_CLKB.n19 VSS 0.07459f
C4006 O_CAPTURE_CLKB.n20 VSS 0.07459f
C4007 O_CAPTURE_CLKB.n21 VSS 0.04837f
C4008 O_CAPTURE_CLKB.n22 VSS 0.04837f
C4009 O_CAPTURE_CLKB.n23 VSS 0.04837f
C4010 O_CAPTURE_CLKB.n24 VSS 0.07459f
C4011 O_CAPTURE_CLKB.n25 VSS 0.07459f
C4012 O_CAPTURE_CLKB.n26 VSS 0.0705f
C4013 O_CAPTURE_CLKB.n27 VSS 0.12373f
C4014 O_CAPTURE_CLKB.n28 VSS 7.45643f
C4015 EVEN_Q.t5 VSS 1.30833f
C4016 EVEN_Q.t0 VSS 0.31666f
C4017 EVEN_Q.t4 VSS 0.31666f
C4018 EVEN_Q.n0 VSS 0.95179f
C4019 EVEN_Q.n1 VSS 0.46942f
C4020 EVEN_Q.t6 VSS 1.30323f
C4021 EVEN_Q.n2 VSS 1.50424f
C4022 EVEN_Q.t3 VSS 0.31666f
C4023 EVEN_Q.t1 VSS 0.31666f
C4024 EVEN_Q.n3 VSS 0.94983f
C4025 EVEN_Q.t2 VSS 1.29902f
C4026 EVEN_Q.n4 VSS 0.478f
C4027 EVEN_Q.n5 VSS 2.99553f
C4028 EVEN_QB.t6 VSS 1.23849f
C4029 EVEN_QB.t4 VSS 0.30028f
C4030 EVEN_QB.t3 VSS 0.30028f
C4031 EVEN_QB.n0 VSS 0.90047f
C4032 EVEN_QB.n1 VSS 0.44411f
C4033 EVEN_QB.t1 VSS 1.23367f
C4034 EVEN_QB.n2 VSS 1.42314f
C4035 EVEN_QB.t2 VSS 0.30028f
C4036 EVEN_QB.t0 VSS 0.30028f
C4037 EVEN_QB.n3 VSS 0.89862f
C4038 EVEN_QB.t5 VSS 1.22968f
C4039 EVEN_QB.n4 VSS 0.45223f
C4040 EVEN_QB.n5 VSS 4.71698f
C4041 ODD_QB.t1 VSS 1.12327f
C4042 ODD_QB.t4 VSS 0.28473f
C4043 ODD_QB.t6 VSS 0.28473f
C4044 ODD_QB.n0 VSS 0.8045f
C4045 ODD_QB.n1 VSS 0.39678f
C4046 ODD_QB.t5 VSS 1.11896f
C4047 ODD_QB.n2 VSS 1.21079f
C4048 ODD_QB.t0 VSS 0.28473f
C4049 ODD_QB.t2 VSS 0.28473f
C4050 ODD_QB.n3 VSS 0.80285f
C4051 ODD_QB.t3 VSS 1.1154f
C4052 ODD_QB.n4 VSS 0.41162f
C4053 ODD_QB.n5 VSS 4.3519f
C4054 ODD_Q.t1 VSS 1.33923f
C4055 ODD_Q.t5 VSS 0.326f
C4056 ODD_Q.t6 VSS 0.326f
C4057 ODD_Q.n0 VSS 0.97244f
C4058 ODD_Q.n1 VSS 0.47961f
C4059 ODD_Q.t2 VSS 1.33402f
C4060 ODD_Q.n2 VSS 1.51482f
C4061 ODD_Q.t0 VSS 0.326f
C4062 ODD_Q.t4 VSS 0.326f
C4063 ODD_Q.n3 VSS 0.97044f
C4064 ODD_Q.t3 VSS 1.32972f
C4065 ODD_Q.n4 VSS 0.48981f
C4066 ODD_Q.n5 VSS 2.90226f
C4067 FE_E_N.n0 VSS 0.0414f
C4068 FE_E_N.n1 VSS 0.14301f
C4069 FE_E_N.n2 VSS 0.07069f
C4070 FE_E_N.n3 VSS 0.07577f
C4071 FE_E_N.n4 VSS 0.07577f
C4072 FE_E_N.n5 VSS 0.14301f
C4073 FE_E_N.n6 VSS 0.07069f
C4074 FE_E_N.n7 VSS 0.07577f
C4075 FE_E_N.n8 VSS 0.07577f
C4076 FE_E_N.n9 VSS 0.07577f
C4077 FE_E_N.n10 VSS 0.07577f
C4078 FE_E_N.n11 VSS 0.0414f
C4079 FE_E_N.n12 VSS 0.27018f
C4080 FE_E_N.n13 VSS 0.06968f
C4081 FE_E_N.n14 VSS 0.07577f
C4082 FE_E_N.n15 VSS 0.07577f
C4083 FE_E_N.n16 VSS 0.06968f
C4084 FE_E_N.n17 VSS 0.20867f
C4085 FE_E_N.n18 VSS 7.41709f
C4086 FE_E_N.t4 VSS 0.64082f
C4087 FE_E_N.t5 VSS 0.17376f
C4088 FE_E_N.t6 VSS 0.17376f
C4089 FE_E_N.n19 VSS 0.44782f
C4090 FE_E_N.n20 VSS 0.22087f
C4091 FE_E_N.t11 VSS 0.64082f
C4092 FE_E_N.t9 VSS 0.17376f
C4093 FE_E_N.t10 VSS 0.17376f
C4094 FE_E_N.n21 VSS 0.44782f
C4095 FE_E_N.n22 VSS 0.24615f
C4096 FE_E_N.t7 VSS 0.17376f
C4097 FE_E_N.t8 VSS 0.17376f
C4098 FE_E_N.n23 VSS 0.44782f
C4099 FE_E_N.n24 VSS 0.10321f
C4100 FE_E_N.n25 VSS 0.1003f
C4101 FE_E_N.t12 VSS 0.63975f
C4102 FE_E_N.t13 VSS 0.17376f
C4103 FE_E_N.t0 VSS 0.17376f
C4104 FE_E_N.n26 VSS 0.44452f
C4105 FE_E_N.n27 VSS 0.25052f
C4106 FE_E_N.t1 VSS 0.17376f
C4107 FE_E_N.t2 VSS 0.17376f
C4108 FE_E_N.n28 VSS 0.44452f
C4109 FE_E_N.n29 VSS 0.12548f
C4110 FE_E_N.t3 VSS 0.63438f
C4111 FE_E_N.n30 VSS 0.21396f
C4112 FE_E_N.n31 VSS 0.65891f
C4113 FE_E_N.n32 VSS 7.58218f
C4114 FE_E_P.n0 VSS 0.04106f
C4115 FE_E_P.n1 VSS 0.14185f
C4116 FE_E_P.n2 VSS 0.07011f
C4117 FE_E_P.n3 VSS 0.07515f
C4118 FE_E_P.n4 VSS 0.07515f
C4119 FE_E_P.n5 VSS 0.14185f
C4120 FE_E_P.n6 VSS 0.07011f
C4121 FE_E_P.n7 VSS 0.07515f
C4122 FE_E_P.n8 VSS 0.07515f
C4123 FE_E_P.n9 VSS 0.07515f
C4124 FE_E_P.n10 VSS 0.07515f
C4125 FE_E_P.n11 VSS 0.04106f
C4126 FE_E_P.n12 VSS 0.26798f
C4127 FE_E_P.n13 VSS 0.06912f
C4128 FE_E_P.n14 VSS 0.07515f
C4129 FE_E_P.n15 VSS 0.07515f
C4130 FE_E_P.n16 VSS 0.06912f
C4131 FE_E_P.n17 VSS 0.20698f
C4132 FE_E_P.n18 VSS 7.85988f
C4133 FE_E_P.t8 VSS 0.6396f
C4134 FE_E_P.t9 VSS 0.17626f
C4135 FE_E_P.t10 VSS 0.17626f
C4136 FE_E_P.n19 VSS 0.44418f
C4137 FE_E_P.n20 VSS 0.21907f
C4138 FE_E_P.t1 VSS 0.6396f
C4139 FE_E_P.t13 VSS 0.17626f
C4140 FE_E_P.t0 VSS 0.17626f
C4141 FE_E_P.n21 VSS 0.44418f
C4142 FE_E_P.n22 VSS 0.24415f
C4143 FE_E_P.t11 VSS 0.17626f
C4144 FE_E_P.t12 VSS 0.17626f
C4145 FE_E_P.n23 VSS 0.44418f
C4146 FE_E_P.n24 VSS 0.10237f
C4147 FE_E_P.n25 VSS 0.08888f
C4148 FE_E_P.t7 VSS 0.63854f
C4149 FE_E_P.t5 VSS 0.17626f
C4150 FE_E_P.t6 VSS 0.17626f
C4151 FE_E_P.n26 VSS 0.44091f
C4152 FE_E_P.n27 VSS 0.24849f
C4153 FE_E_P.t3 VSS 0.17626f
C4154 FE_E_P.t4 VSS 0.17626f
C4155 FE_E_P.n28 VSS 0.44091f
C4156 FE_E_P.n29 VSS 0.13073f
C4157 FE_E_P.t2 VSS 0.63281f
C4158 FE_E_P.n30 VSS 0.30377f
C4159 FE_E_P.n31 VSS 0.68508f
C4160 FE_O_P.n0 VSS 0.0377f
C4161 FE_O_P.n1 VSS 0.13025f
C4162 FE_O_P.n2 VSS 0.06438f
C4163 FE_O_P.n3 VSS 0.06901f
C4164 FE_O_P.n4 VSS 0.06901f
C4165 FE_O_P.n5 VSS 0.13025f
C4166 FE_O_P.n6 VSS 0.06438f
C4167 FE_O_P.n7 VSS 0.06901f
C4168 FE_O_P.n8 VSS 0.06901f
C4169 FE_O_P.n9 VSS 0.06901f
C4170 FE_O_P.n10 VSS 0.06901f
C4171 FE_O_P.n11 VSS 0.0377f
C4172 FE_O_P.n12 VSS 0.24607f
C4173 FE_O_P.n13 VSS 0.06346f
C4174 FE_O_P.n14 VSS 0.06901f
C4175 FE_O_P.n15 VSS 0.06901f
C4176 FE_O_P.n16 VSS 0.06346f
C4177 FE_O_P.n17 VSS 0.19005f
C4178 FE_O_P.n18 VSS 6.96851f
C4179 FE_O_P.t11 VSS 0.59157f
C4180 FE_O_P.t12 VSS 0.16604f
C4181 FE_O_P.t13 VSS 0.16604f
C4182 FE_O_P.n19 VSS 0.40786f
C4183 FE_O_P.n20 VSS 0.22419f
C4184 FE_O_P.t0 VSS 0.16604f
C4185 FE_O_P.t1 VSS 0.16604f
C4186 FE_O_P.n21 VSS 0.40786f
C4187 FE_O_P.n22 VSS 0.094f
C4188 FE_O_P.t4 VSS 0.59157f
C4189 FE_O_P.t2 VSS 0.16604f
C4190 FE_O_P.t3 VSS 0.16604f
C4191 FE_O_P.n23 VSS 0.40786f
C4192 FE_O_P.n24 VSS 0.20115f
C4193 FE_O_P.n25 VSS 0.09135f
C4194 FE_O_P.t5 VSS 0.58556f
C4195 FE_O_P.t10 VSS 0.59059f
C4196 FE_O_P.t8 VSS 0.16604f
C4197 FE_O_P.t9 VSS 0.16604f
C4198 FE_O_P.n26 VSS 0.40485f
C4199 FE_O_P.n27 VSS 0.22817f
C4200 FE_O_P.t6 VSS 0.16604f
C4201 FE_O_P.t7 VSS 0.16604f
C4202 FE_O_P.n28 VSS 0.40485f
C4203 FE_O_P.n29 VSS 0.11428f
C4204 FE_O_P.n30 VSS 0.19487f
C4205 FE_O_P.n31 VSS 0.60056f
C4206 FE_O_N.n0 VSS 0.04057f
C4207 FE_O_N.n1 VSS 0.14014f
C4208 FE_O_N.n2 VSS 0.06927f
C4209 FE_O_N.n3 VSS 0.07425f
C4210 FE_O_N.n4 VSS 0.07425f
C4211 FE_O_N.n5 VSS 0.14014f
C4212 FE_O_N.n6 VSS 0.06927f
C4213 FE_O_N.n7 VSS 0.07425f
C4214 FE_O_N.n8 VSS 0.07425f
C4215 FE_O_N.n9 VSS 0.07425f
C4216 FE_O_N.n10 VSS 0.07425f
C4217 FE_O_N.n11 VSS 0.04057f
C4218 FE_O_N.n12 VSS 0.26476f
C4219 FE_O_N.n13 VSS 0.06829f
C4220 FE_O_N.n14 VSS 0.07425f
C4221 FE_O_N.n15 VSS 0.07425f
C4222 FE_O_N.n16 VSS 0.06829f
C4223 FE_O_N.n17 VSS 0.20449f
C4224 FE_O_N.n18 VSS 7.57353f
C4225 FE_O_N.t6 VSS 0.63303f
C4226 FE_O_N.t7 VSS 0.17523f
C4227 FE_O_N.t8 VSS 0.17523f
C4228 FE_O_N.n19 VSS 0.43885f
C4229 FE_O_N.n20 VSS 0.24122f
C4230 FE_O_N.t9 VSS 0.17523f
C4231 FE_O_N.t2 VSS 0.17523f
C4232 FE_O_N.n21 VSS 0.43885f
C4233 FE_O_N.n22 VSS 0.10114f
C4234 FE_O_N.t5 VSS 0.63303f
C4235 FE_O_N.t3 VSS 0.17523f
C4236 FE_O_N.t4 VSS 0.17523f
C4237 FE_O_N.n23 VSS 0.43885f
C4238 FE_O_N.n24 VSS 0.21644f
C4239 FE_O_N.n25 VSS 0.08781f
C4240 FE_O_N.t0 VSS 0.63198f
C4241 FE_O_N.t1 VSS 0.17523f
C4242 FE_O_N.t10 VSS 0.17523f
C4243 FE_O_N.n26 VSS 0.43561f
C4244 FE_O_N.n27 VSS 0.2455f
C4245 FE_O_N.t11 VSS 0.17523f
C4246 FE_O_N.t12 VSS 0.17523f
C4247 FE_O_N.n28 VSS 0.43561f
C4248 FE_O_N.n29 VSS 0.12916f
C4249 FE_O_N.t13 VSS 0.6263f
C4250 FE_O_N.n30 VSS 0.30013f
C4251 FE_O_N.n31 VSS 0.67632f
C4252 FE_O_N.n32 VSS 7.30186f
C4253 E_CAPTURE_CLK.n0 VSS 0.03705f
C4254 E_CAPTURE_CLK.n1 VSS 0.02538f
C4255 E_CAPTURE_CLK.n2 VSS 0.02538f
C4256 E_CAPTURE_CLK.n3 VSS 0.02538f
C4257 E_CAPTURE_CLK.n4 VSS 0.07387f
C4258 E_CAPTURE_CLK.n5 VSS 0.03651f
C4259 E_CAPTURE_CLK.n6 VSS 0.03914f
C4260 E_CAPTURE_CLK.n7 VSS 0.03914f
C4261 E_CAPTURE_CLK.n8 VSS 0.03914f
C4262 E_CAPTURE_CLK.n9 VSS 0.03914f
C4263 E_CAPTURE_CLK.n10 VSS 0.03914f
C4264 E_CAPTURE_CLK.n11 VSS 0.03914f
C4265 E_CAPTURE_CLK.n12 VSS 0.02138f
C4266 E_CAPTURE_CLK.n13 VSS 0.17344f
C4267 E_CAPTURE_CLK.n14 VSS 0.036f
C4268 E_CAPTURE_CLK.n15 VSS 0.02538f
C4269 E_CAPTURE_CLK.n16 VSS 0.03914f
C4270 E_CAPTURE_CLK.n17 VSS 0.03914f
C4271 E_CAPTURE_CLK.n18 VSS 0.03651f
C4272 E_CAPTURE_CLK.n19 VSS 0.07387f
C4273 E_CAPTURE_CLK.n20 VSS 0.02538f
C4274 E_CAPTURE_CLK.n21 VSS 0.03914f
C4275 E_CAPTURE_CLK.n22 VSS 0.03914f
C4276 E_CAPTURE_CLK.n23 VSS 0.03914f
C4277 E_CAPTURE_CLK.n24 VSS 0.03914f
C4278 E_CAPTURE_CLK.n25 VSS 0.02138f
C4279 E_CAPTURE_CLK.n26 VSS 0.07131f
C4280 E_CAPTURE_CLK.n27 VSS 1.62962f
C4281 O_CAPTURE_CLK.n0 VSS 0.0388f
C4282 O_CAPTURE_CLK.n1 VSS 0.02658f
C4283 O_CAPTURE_CLK.n2 VSS 0.02658f
C4284 O_CAPTURE_CLK.n3 VSS 0.02658f
C4285 O_CAPTURE_CLK.n4 VSS 0.07736f
C4286 O_CAPTURE_CLK.n5 VSS 0.03824f
C4287 O_CAPTURE_CLK.n6 VSS 0.04099f
C4288 O_CAPTURE_CLK.n7 VSS 0.04099f
C4289 O_CAPTURE_CLK.n8 VSS 0.04099f
C4290 O_CAPTURE_CLK.n9 VSS 0.04099f
C4291 O_CAPTURE_CLK.n10 VSS 0.04099f
C4292 O_CAPTURE_CLK.n11 VSS 0.04099f
C4293 O_CAPTURE_CLK.n12 VSS 0.02239f
C4294 O_CAPTURE_CLK.n13 VSS 0.23908f
C4295 O_CAPTURE_CLK.n14 VSS 0.0377f
C4296 O_CAPTURE_CLK.n15 VSS 0.02658f
C4297 O_CAPTURE_CLK.n16 VSS 0.04099f
C4298 O_CAPTURE_CLK.n17 VSS 0.04099f
C4299 O_CAPTURE_CLK.n18 VSS 0.03824f
C4300 O_CAPTURE_CLK.n19 VSS 0.07736f
C4301 O_CAPTURE_CLK.n20 VSS 0.02658f
C4302 O_CAPTURE_CLK.n21 VSS 0.04099f
C4303 O_CAPTURE_CLK.n22 VSS 0.04099f
C4304 O_CAPTURE_CLK.n23 VSS 0.04099f
C4305 O_CAPTURE_CLK.n24 VSS 0.04099f
C4306 O_CAPTURE_CLK.n25 VSS 0.02239f
C4307 O_CAPTURE_CLK.n26 VSS 0.12591f
C4308 O_CAPTURE_CLK.n27 VSS 1.83383f
C4309 E_REGEN_CLKB.n0 VSS 0.17455f
C4310 E_REGEN_CLKB.n1 VSS 0.17915f
C4311 E_REGEN_CLKB.n2 VSS 0.12632f
C4312 E_REGEN_CLKB.n3 VSS 0.51947f
C4313 E_REGEN_CLKB.n4 VSS 0.1948f
C4314 E_REGEN_CLKB.n5 VSS 0.12632f
C4315 E_REGEN_CLKB.n6 VSS 0.1948f
C4316 E_REGEN_CLKB.n7 VSS 0.25312f
C4317 E_REGEN_CLKB.n8 VSS 0.27301f
C4318 E_REGEN_CLKB.n9 VSS 0.27301f
C4319 E_REGEN_CLKB.n10 VSS 0.27301f
C4320 E_REGEN_CLKB.n11 VSS 0.53936f
C4321 E_REGEN_CLKB.n12 VSS 0.18173f
C4322 E_REGEN_CLKB.n13 VSS 0.36767f
C4323 E_REGEN_CLKB.n14 VSS 0.1948f
C4324 E_REGEN_CLKB.n15 VSS 0.1948f
C4325 E_REGEN_CLKB.n16 VSS 0.1948f
C4326 E_REGEN_CLKB.n17 VSS 0.1948f
C4327 E_REGEN_CLKB.n18 VSS 0.10643f
C4328 E_REGEN_CLKB.n19 VSS 0.31245f
C4329 E_REGEN_CLKB.n20 VSS 3.46727f
C4330 E_REGEN_CLKB.n21 VSS 0.42113f
C4331 E_REGEN_CLKB.n22 VSS 0.10643f
C4332 E_REGEN_CLKB.n23 VSS 0.1948f
C4333 E_REGEN_CLKB.n24 VSS 0.27301f
C4334 E_REGEN_CLKB.n25 VSS 0.12632f
C4335 E_REGEN_CLKB.n26 VSS 0.12632f
C4336 E_REGEN_CLKB.n27 VSS 0.12632f
C4337 E_REGEN_CLKB.n28 VSS 0.36767f
C4338 E_REGEN_CLKB.n29 VSS 0.27301f
C4339 E_REGEN_CLKB.n30 VSS 0.53936f
C4340 E_REGEN_CLKB.n31 VSS 0.18173f
C4341 E_REGEN_CLKB.n32 VSS 0.1948f
C4342 E_REGEN_CLKB.n33 VSS 0.1948f
C4343 E_REGEN_CLKB.n34 VSS 0.1948f
C4344 E_REGEN_CLKB.n35 VSS 0.1948f
C4345 E_REGEN_CLKB.n36 VSS 0.27301f
C4346 E_REGEN_CLKB.n37 VSS 0.27301f
C4347 E_REGEN_CLKB.n38 VSS 0.25312f
C4348 E_REGEN_CLKB.n39 VSS 0.1948f
C4349 E_REGEN_CLKB.n40 VSS 0.18441f
C4350 E_REGEN_CLKB.n41 VSS 0.18813f
C4351 E_REGEN_CLKB.n42 VSS 2.11028f
C4352 E_REGEN_CLKB.n43 VSS 9.00499f
C4353 O_REGEN_CLKB.n0 VSS 0.17455f
C4354 O_REGEN_CLKB.n1 VSS 0.10643f
C4355 O_REGEN_CLKB.n2 VSS 0.1948f
C4356 O_REGEN_CLKB.n3 VSS 0.27301f
C4357 O_REGEN_CLKB.n4 VSS 0.12632f
C4358 O_REGEN_CLKB.n5 VSS 0.12632f
C4359 O_REGEN_CLKB.n6 VSS 0.36767f
C4360 O_REGEN_CLKB.n7 VSS 0.53936f
C4361 O_REGEN_CLKB.n8 VSS 0.18173f
C4362 O_REGEN_CLKB.n9 VSS 0.1948f
C4363 O_REGEN_CLKB.n10 VSS 0.1948f
C4364 O_REGEN_CLKB.n11 VSS 0.1948f
C4365 O_REGEN_CLKB.n12 VSS 0.27301f
C4366 O_REGEN_CLKB.n13 VSS 0.27301f
C4367 O_REGEN_CLKB.n14 VSS 0.25312f
C4368 O_REGEN_CLKB.n15 VSS 0.1948f
C4369 O_REGEN_CLKB.n16 VSS 0.51947f
C4370 O_REGEN_CLKB.n17 VSS 0.1948f
C4371 O_REGEN_CLKB.n18 VSS 0.17915f
C4372 O_REGEN_CLKB.n19 VSS 0.31245f
C4373 O_REGEN_CLKB.n20 VSS 3.46727f
C4374 O_REGEN_CLKB.n21 VSS 0.42113f
C4375 O_REGEN_CLKB.n22 VSS 0.18441f
C4376 O_REGEN_CLKB.n23 VSS 0.12632f
C4377 O_REGEN_CLKB.n24 VSS 0.12632f
C4378 O_REGEN_CLKB.n25 VSS 0.12632f
C4379 O_REGEN_CLKB.n26 VSS 0.1948f
C4380 O_REGEN_CLKB.n27 VSS 0.25312f
C4381 O_REGEN_CLKB.n28 VSS 0.27301f
C4382 O_REGEN_CLKB.n29 VSS 0.27301f
C4383 O_REGEN_CLKB.n30 VSS 0.27301f
C4384 O_REGEN_CLKB.n31 VSS 0.27301f
C4385 O_REGEN_CLKB.n32 VSS 0.53936f
C4386 O_REGEN_CLKB.n33 VSS 0.18173f
C4387 O_REGEN_CLKB.n34 VSS 0.36767f
C4388 O_REGEN_CLKB.n35 VSS 0.1948f
C4389 O_REGEN_CLKB.n36 VSS 0.1948f
C4390 O_REGEN_CLKB.n37 VSS 0.1948f
C4391 O_REGEN_CLKB.n38 VSS 0.1948f
C4392 O_REGEN_CLKB.n39 VSS 0.1948f
C4393 O_REGEN_CLKB.n40 VSS 0.10643f
C4394 O_REGEN_CLKB.n41 VSS 0.18813f
C4395 O_REGEN_CLKB.n42 VSS 2.11028f
C4396 O_REGEN_CLKB.n43 VSS 9.00499f
C4397 E_REGEN_CLK.n0 VSS 0.81622f
C4398 E_REGEN_CLK.n1 VSS 0.40958f
C4399 E_REGEN_CLK.n2 VSS 0.09349f
C4400 E_REGEN_CLK.n3 VSS 0.14417f
C4401 E_REGEN_CLK.n4 VSS 0.20205f
C4402 E_REGEN_CLK.n5 VSS 0.09349f
C4403 E_REGEN_CLK.n6 VSS 0.09349f
C4404 E_REGEN_CLK.n7 VSS 0.09349f
C4405 E_REGEN_CLK.n8 VSS 0.2721f
C4406 E_REGEN_CLK.n9 VSS 0.20205f
C4407 E_REGEN_CLK.n10 VSS 0.20205f
C4408 E_REGEN_CLK.n11 VSS 0.39916f
C4409 E_REGEN_CLK.n12 VSS 0.1345f
C4410 E_REGEN_CLK.n13 VSS 0.14417f
C4411 E_REGEN_CLK.n14 VSS 0.14417f
C4412 E_REGEN_CLK.n15 VSS 0.14417f
C4413 E_REGEN_CLK.n16 VSS 0.14417f
C4414 E_REGEN_CLK.n17 VSS 0.14417f
C4415 E_REGEN_CLK.n18 VSS 0.20205f
C4416 E_REGEN_CLK.n19 VSS 0.20205f
C4417 E_REGEN_CLK.n20 VSS 0.31304f
C4418 E_REGEN_CLK.n21 VSS 0.13625f
C4419 E_REGEN_CLK.n22 VSS 0.20448f
C4420 E_REGEN_CLK.n23 VSS 0.09349f
C4421 E_REGEN_CLK.n24 VSS 0.09349f
C4422 E_REGEN_CLK.n25 VSS 0.09349f
C4423 E_REGEN_CLK.n26 VSS 0.09349f
C4424 E_REGEN_CLK.n27 VSS 0.14417f
C4425 E_REGEN_CLK.n28 VSS 0.31304f
C4426 E_REGEN_CLK.n29 VSS 0.20205f
C4427 E_REGEN_CLK.n30 VSS 0.20205f
C4428 E_REGEN_CLK.n31 VSS 0.20205f
C4429 E_REGEN_CLK.n32 VSS 0.20205f
C4430 E_REGEN_CLK.n33 VSS 0.20205f
C4431 E_REGEN_CLK.n34 VSS 0.39916f
C4432 E_REGEN_CLK.n35 VSS 0.1345f
C4433 E_REGEN_CLK.n36 VSS 0.2721f
C4434 E_REGEN_CLK.n37 VSS 0.14417f
C4435 E_REGEN_CLK.n38 VSS 0.14417f
C4436 E_REGEN_CLK.n39 VSS 0.14417f
C4437 E_REGEN_CLK.n40 VSS 0.14417f
C4438 E_REGEN_CLK.n41 VSS 0.14417f
C4439 E_REGEN_CLK.n42 VSS 0.13625f
C4440 E_REGEN_CLK.n43 VSS 0.20448f
C4441 E_REGEN_CLK.n44 VSS 0.34583f
C4442 E_REGEN_CLK.n45 VSS 1.08296f
C4443 E_REGEN_CLK.n46 VSS 0.07877f
C4444 E_REGEN_CLK.n47 VSS 0.2721f
C4445 E_REGEN_CLK.n48 VSS 0.1345f
C4446 E_REGEN_CLK.n49 VSS 0.14417f
C4447 E_REGEN_CLK.n50 VSS 0.14417f
C4448 E_REGEN_CLK.n51 VSS 0.14417f
C4449 E_REGEN_CLK.n52 VSS 0.1345f
C4450 E_REGEN_CLK.n53 VSS 0.2721f
C4451 E_REGEN_CLK.n54 VSS 0.14417f
C4452 E_REGEN_CLK.n55 VSS 0.14417f
C4453 E_REGEN_CLK.n56 VSS 0.14417f
C4454 E_REGEN_CLK.n57 VSS 0.07877f
C4455 E_REGEN_CLK.n58 VSS 0.51577f
C4456 E_REGEN_CLK.n59 VSS 1.55282f
C4457 E_REGEN_CLK.n60 VSS 2.56208f
C4458 E_REGEN_CLK.n61 VSS 0.33721f
C4459 E_REGEN_CLK.n62 VSS 0.09349f
C4460 E_REGEN_CLK.n63 VSS 0.14417f
C4461 E_REGEN_CLK.n64 VSS 0.20205f
C4462 E_REGEN_CLK.n65 VSS 0.14417f
C4463 E_REGEN_CLK.n66 VSS 0.09349f
C4464 E_REGEN_CLK.n67 VSS 0.1345f
C4465 E_REGEN_CLK.n68 VSS 0.14417f
C4466 E_REGEN_CLK.n69 VSS 0.39916f
C4467 E_REGEN_CLK.n70 VSS 0.20205f
C4468 E_REGEN_CLK.n71 VSS 0.14417f
C4469 E_REGEN_CLK.n72 VSS 0.2721f
C4470 E_REGEN_CLK.n73 VSS 0.09349f
C4471 E_REGEN_CLK.n74 VSS 0.09349f
C4472 E_REGEN_CLK.n75 VSS 0.14417f
C4473 E_REGEN_CLK.n76 VSS 0.20205f
C4474 E_REGEN_CLK.n77 VSS 0.20205f
C4475 E_REGEN_CLK.n78 VSS 0.20205f
C4476 E_REGEN_CLK.n79 VSS 0.14417f
C4477 E_REGEN_CLK.n80 VSS 0.13625f
C4478 E_REGEN_CLK.n81 VSS 0.16511f
C4479 E_REGEN_CLK.n82 VSS 1.27388f
C4480 E_REGEN_CLK.n83 VSS 1.49796f
C4481 E_REGEN_CLK.n84 VSS 0.57533f
C4482 E_REGEN_CLK.n85 VSS 3.84382f
C4483 O_REGEN_CLK.n0 VSS 0.81622f
C4484 O_REGEN_CLK.n1 VSS 0.40958f
C4485 O_REGEN_CLK.n2 VSS 0.09349f
C4486 O_REGEN_CLK.n3 VSS 0.14417f
C4487 O_REGEN_CLK.n4 VSS 0.20205f
C4488 O_REGEN_CLK.n5 VSS 0.09349f
C4489 O_REGEN_CLK.n6 VSS 0.09349f
C4490 O_REGEN_CLK.n7 VSS 0.09349f
C4491 O_REGEN_CLK.n8 VSS 0.2721f
C4492 O_REGEN_CLK.n9 VSS 0.20205f
C4493 O_REGEN_CLK.n10 VSS 0.20205f
C4494 O_REGEN_CLK.n11 VSS 0.39916f
C4495 O_REGEN_CLK.n12 VSS 0.1345f
C4496 O_REGEN_CLK.n13 VSS 0.14417f
C4497 O_REGEN_CLK.n14 VSS 0.14417f
C4498 O_REGEN_CLK.n15 VSS 0.14417f
C4499 O_REGEN_CLK.n16 VSS 0.14417f
C4500 O_REGEN_CLK.n17 VSS 0.14417f
C4501 O_REGEN_CLK.n18 VSS 0.20205f
C4502 O_REGEN_CLK.n19 VSS 0.20205f
C4503 O_REGEN_CLK.n20 VSS 0.31304f
C4504 O_REGEN_CLK.n21 VSS 0.13625f
C4505 O_REGEN_CLK.n22 VSS 0.20448f
C4506 O_REGEN_CLK.n23 VSS 0.09349f
C4507 O_REGEN_CLK.n24 VSS 0.14417f
C4508 O_REGEN_CLK.n25 VSS 0.20205f
C4509 O_REGEN_CLK.n26 VSS 0.09349f
C4510 O_REGEN_CLK.n27 VSS 0.09349f
C4511 O_REGEN_CLK.n28 VSS 0.09349f
C4512 O_REGEN_CLK.n29 VSS 0.2721f
C4513 O_REGEN_CLK.n30 VSS 0.20205f
C4514 O_REGEN_CLK.n31 VSS 0.20205f
C4515 O_REGEN_CLK.n32 VSS 0.39916f
C4516 O_REGEN_CLK.n33 VSS 0.1345f
C4517 O_REGEN_CLK.n34 VSS 0.14417f
C4518 O_REGEN_CLK.n35 VSS 0.14417f
C4519 O_REGEN_CLK.n36 VSS 0.14417f
C4520 O_REGEN_CLK.n37 VSS 0.14417f
C4521 O_REGEN_CLK.n38 VSS 0.14417f
C4522 O_REGEN_CLK.n39 VSS 0.20205f
C4523 O_REGEN_CLK.n40 VSS 0.20205f
C4524 O_REGEN_CLK.n41 VSS 0.31304f
C4525 O_REGEN_CLK.n42 VSS 0.13625f
C4526 O_REGEN_CLK.n43 VSS 0.20448f
C4527 O_REGEN_CLK.n44 VSS 0.34583f
C4528 O_REGEN_CLK.n45 VSS 1.08296f
C4529 O_REGEN_CLK.n46 VSS 0.07877f
C4530 O_REGEN_CLK.n47 VSS 0.2721f
C4531 O_REGEN_CLK.n48 VSS 0.1345f
C4532 O_REGEN_CLK.n49 VSS 0.14417f
C4533 O_REGEN_CLK.n50 VSS 0.14417f
C4534 O_REGEN_CLK.n51 VSS 0.14417f
C4535 O_REGEN_CLK.n52 VSS 0.1345f
C4536 O_REGEN_CLK.n53 VSS 0.2721f
C4537 O_REGEN_CLK.n54 VSS 0.14417f
C4538 O_REGEN_CLK.n55 VSS 0.14417f
C4539 O_REGEN_CLK.n56 VSS 0.14417f
C4540 O_REGEN_CLK.n57 VSS 0.07877f
C4541 O_REGEN_CLK.n58 VSS 0.51577f
C4542 O_REGEN_CLK.n59 VSS 1.55282f
C4543 O_REGEN_CLK.n60 VSS 2.56208f
C4544 O_REGEN_CLK.n61 VSS 0.33721f
C4545 O_REGEN_CLK.n62 VSS 0.09349f
C4546 O_REGEN_CLK.n63 VSS 0.09349f
C4547 O_REGEN_CLK.n64 VSS 0.09349f
C4548 O_REGEN_CLK.n65 VSS 0.09349f
C4549 O_REGEN_CLK.n66 VSS 0.2721f
C4550 O_REGEN_CLK.n67 VSS 0.20205f
C4551 O_REGEN_CLK.n68 VSS 0.20205f
C4552 O_REGEN_CLK.n69 VSS 0.20205f
C4553 O_REGEN_CLK.n70 VSS 0.20205f
C4554 O_REGEN_CLK.n71 VSS 0.20205f
C4555 O_REGEN_CLK.n72 VSS 0.39916f
C4556 O_REGEN_CLK.n73 VSS 0.1345f
C4557 O_REGEN_CLK.n74 VSS 0.14417f
C4558 O_REGEN_CLK.n75 VSS 0.14417f
C4559 O_REGEN_CLK.n76 VSS 0.14417f
C4560 O_REGEN_CLK.n77 VSS 0.14417f
C4561 O_REGEN_CLK.n78 VSS 0.14417f
C4562 O_REGEN_CLK.n79 VSS 0.14417f
C4563 O_REGEN_CLK.n80 VSS 0.13625f
C4564 O_REGEN_CLK.n81 VSS 0.16511f
C4565 O_REGEN_CLK.n82 VSS 1.27388f
C4566 O_REGEN_CLK.n83 VSS 1.49797f
C4567 O_REGEN_CLK.n84 VSS 0.57533f
C4568 O_REGEN_CLK.n85 VSS 3.84382f
C4569 E_SENSE_CLK.n0 VSS 0.35044f
C4570 E_SENSE_CLK.n1 VSS 0.35044f
C4571 E_SENSE_CLK.n2 VSS 2.18951f
C4572 E_SENSE_CLK.n3 VSS 0.43843f
C4573 E_SENSE_CLK.n4 VSS 2.26622f
C4574 E_SENSE_CLK.n5 VSS 1.65396f
C4575 E_SENSE_CLK.n6 VSS 6.97478f
C4576 O_SENSE_CLK.n0 VSS 0.35044f
C4577 O_SENSE_CLK.n1 VSS 0.35044f
C4578 O_SENSE_CLK.n2 VSS 2.18951f
C4579 O_SENSE_CLK.n3 VSS 0.43843f
C4580 O_SENSE_CLK.n4 VSS 2.26622f
C4581 O_SENSE_CLK.n5 VSS 1.65396f
C4582 O_SENSE_CLK.n6 VSS 6.97478f
C4583 SAMP_E_P.t2 VSS 0.14604f
C4584 SAMP_E_P.n0 VSS 0.40502f
C4585 SAMP_E_P.n1 VSS 0.97957f
C4586 SAMP_E_P.n2 VSS 0.09614f
C4587 SAMP_E_P.t3 VSS 0.34171f
C4588 SAMP_E_P.n3 VSS 0.09849f
C4589 SAMP_E_P.t4 VSS 0.34171f
C4590 SAMP_E_P.n4 VSS 0.09849f
C4591 SAMP_E_P.n5 VSS 0.08374f
C4592 SAMP_E_P.n6 VSS 0.30761f
C4593 SAMP_E_P.t0 VSS 0.34451f
C4594 SAMP_E_P.t1 VSS 0.34441f
C4595 SAMP_E_P.n7 VSS 0.22787f
C4596 SAMP_E_P.n8 VSS 0.72311f
C4597 SAMP_E_P.n9 VSS 1.89647f
C4598 SAMP_E_P.n10 VSS 1.88655f
C4599 SAMP_E_N.t4 VSS 0.10963f
C4600 SAMP_E_N.t3 VSS 0.26998f
C4601 SAMP_E_N.t2 VSS 0.27005f
C4602 SAMP_E_N.n0 VSS 0.17105f
C4603 SAMP_E_N.n1 VSS 0.21765f
C4604 SAMP_E_N.n2 VSS 0.72649f
C4605 SAMP_E_N.n3 VSS 0.0526f
C4606 SAMP_E_N.t0 VSS 0.28004f
C4607 SAMP_E_N.t1 VSS 0.28004f
C4608 SAMP_E_N.n4 VSS 0.07393f
C4609 SAMP_E_N.n5 VSS 0.07393f
C4610 SAMP_E_N.n6 VSS 0.06286f
C4611 SAMP_E_N.n7 VSS 0.23091f
C4612 SAMP_E_N.n8 VSS 0.54281f
C4613 SAMP_E_N.n9 VSS 1.42361f
C4614 SAMP_E_N.n10 VSS 1.12332f
C4615 E_SENSE_BOOST.n0 VSS 0.04667f
C4616 E_SENSE_BOOST.n1 VSS 0.0554f
C4617 E_SENSE_BOOST.n2 VSS 0.16124f
C4618 E_SENSE_BOOST.n3 VSS 0.0797f
C4619 E_SENSE_BOOST.n4 VSS 0.08543f
C4620 E_SENSE_BOOST.n5 VSS 0.08543f
C4621 E_SENSE_BOOST.n6 VSS 0.08543f
C4622 E_SENSE_BOOST.n7 VSS 0.08543f
C4623 E_SENSE_BOOST.n8 VSS 0.08087f
C4624 E_SENSE_BOOST.n9 VSS 1.44212f
C4625 SAMP_O_P.t0 VSS 0.10995f
C4626 SAMP_O_P.n0 VSS 0.28447f
C4627 SAMP_O_P.n1 VSS 0.79165f
C4628 SAMP_O_P.n2 VSS 0.05276f
C4629 SAMP_O_P.t2 VSS 0.28066f
C4630 SAMP_O_P.n3 VSS 0.07415f
C4631 SAMP_O_P.t1 VSS 0.28066f
C4632 SAMP_O_P.n4 VSS 0.07415f
C4633 SAMP_O_P.n5 VSS 0.06304f
C4634 SAMP_O_P.n6 VSS 0.2316f
C4635 SAMP_O_P.t4 VSS 0.26967f
C4636 SAMP_O_P.t3 VSS 0.26959f
C4637 SAMP_O_P.n7 VSS 0.17156f
C4638 SAMP_O_P.n8 VSS 0.54441f
C4639 SAMP_O_P.n9 VSS 1.42782f
C4640 SAMP_O_P.n10 VSS 1.12665f
C4641 SAMP_O_N.t2 VSS 0.14591f
C4642 SAMP_O_N.t1 VSS 0.3452f
C4643 SAMP_O_N.t0 VSS 0.3453f
C4644 SAMP_O_N.n0 VSS 0.22767f
C4645 SAMP_O_N.n1 VSS 0.30724f
C4646 SAMP_O_N.n2 VSS 0.90469f
C4647 SAMP_O_N.n3 VSS 0.09606f
C4648 SAMP_O_N.t4 VSS 0.34157f
C4649 SAMP_O_N.t3 VSS 0.34157f
C4650 SAMP_O_N.n4 VSS 0.0984f
C4651 SAMP_O_N.n5 VSS 0.0984f
C4652 SAMP_O_N.n6 VSS 0.08366f
C4653 SAMP_O_N.n7 VSS 0.30735f
C4654 SAMP_O_N.n8 VSS 0.72247f
C4655 SAMP_O_N.n9 VSS 1.89481f
C4656 SAMP_O_N.n10 VSS 1.8849f
C4657 O_SENSE_BOOST.n0 VSS 0.08087f
C4658 O_SENSE_BOOST.n1 VSS 0.0554f
C4659 O_SENSE_BOOST.n2 VSS 0.08543f
C4660 O_SENSE_BOOST.n3 VSS 0.0797f
C4661 O_SENSE_BOOST.n4 VSS 0.16124f
C4662 O_SENSE_BOOST.n5 VSS 0.08543f
C4663 O_SENSE_BOOST.n6 VSS 0.08543f
C4664 O_SENSE_BOOST.n7 VSS 0.08543f
C4665 O_SENSE_BOOST.n8 VSS 0.04667f
C4666 O_SENSE_BOOST.n9 VSS 1.44212f
C4667 RX_RESTN.n0 VSS 0.13623f
C4668 RX_RESTN.n1 VSS 0.47066f
C4669 RX_RESTN.n2 VSS 2.92409f
C4670 RX_RESTN.t1 VSS 0.11488f
C4671 RX_RESTN.t2 VSS 0.46315f
C4672 RX_RESTN.t0 VSS 0.46315f
C4673 RX_RESTN.n3 VSS 0.20876f
C4674 RX_RESTN.n4 VSS 1.09392f
C4675 RX_RESTP.n0 VSS 0.46983f
C4676 RX_RESTP.n1 VSS 0.21633f
C4677 RX_RESTP.n2 VSS 3.88442f
C4678 RX_RESTP.t0 VSS 0.11779f
C4679 RX_RESTP.t1 VSS 0.46518f
C4680 RX_RESTP.t2 VSS 0.46518f
C4681 RX_RESTP.n3 VSS 0.21405f
C4682 RX_RESTP.n4 VSS 1.08937f
C4683 SAMP_CLK_P.n0 VSS 0.13015f
C4684 SAMP_CLK_P.n1 VSS 0.25013f
C4685 SAMP_CLK_P.n2 VSS 3.73964f
C4686 SAMP_CLK_N.n0 VSS 0.10938f
C4687 SAMP_CLK_N.n1 VSS 0.22229f
C4688 SAMP_CLK_N.n2 VSS 2.93308f
C4689 SAMP_BIAS.n0 VSS 0.02864f
C4690 SAMP_BIAS.n1 VSS 0.03072f
C4691 SAMP_BIAS.n2 VSS 0.03072f
C4692 SAMP_BIAS.n3 VSS 0.02864f
C4693 SAMP_BIAS.n4 VSS 0.25264f
C4694 SAMP_BIAS.n5 VSS 0.02864f
C4695 SAMP_BIAS.n6 VSS 0.03072f
C4696 SAMP_BIAS.n7 VSS 0.03072f
C4697 SAMP_BIAS.n8 VSS 0.02864f
C4698 SAMP_BIAS.n9 VSS 0.08713f
C4699 SAMP_BIAS.n10 VSS 2.16477f
C4700 REST_BIAS.n0 VSS 0.02944f
C4701 REST_BIAS.n1 VSS 0.03128f
C4702 REST_BIAS.n2 VSS 0.03128f
C4703 REST_BIAS.n3 VSS 0.02944f
C4704 REST_BIAS.n4 VSS 0.22195f
C4705 REST_BIAS.n5 VSS 0.02944f
C4706 REST_BIAS.n6 VSS 0.03128f
C4707 REST_BIAS.n7 VSS 0.03128f
C4708 REST_BIAS.n8 VSS 0.02944f
C4709 REST_BIAS.n9 VSS 0.07827f
C4710 REST_BIAS.n10 VSS 1.38426f
C4711 RX_RAWP.n0 VSS 0.50786f
C4712 RX_RAWP.t0 VSS 0.07485f
C4713 RX_RAWP.t2 VSS 0.23743f
C4714 RX_RAWP.t3 VSS 0.18226f
C4715 RX_RAWP.t1 VSS 0.18231f
C4716 RX_RAWP.n1 VSS 0.32417f
C4717 RX_RAWP.n2 VSS 1.0692f
C4718 RX_RAWP.n3 VSS 0.45242f
C4719 RX_RAWN.n0 VSS 0.47865f
C4720 RX_RAWN.t0 VSS 0.07027f
C4721 RX_RAWN.t3 VSS 0.23918f
C4722 RX_RAWN.t2 VSS 0.17321f
C4723 RX_RAWN.t1 VSS 0.17316f
C4724 RX_RAWN.n1 VSS 0.30433f
C4725 RX_RAWN.n2 VSS 1.00377f
C4726 RX_RAWN.n3 VSS 0.42473f
C4727 RX_BW_EN_N.n0 VSS 2.37285f
C4728 RX_BW_EN_N.n1 VSS 1.30569f
C4729 RX_BW_EN_N.n2 VSS 1.47388f
C4730 VTHP.n0 VSS 0.61322f
C4731 VTHN.n0 VSS 0.63951f
C4732 RX_BIAS.n0 VSS 0.02779f
C4733 RX_BIAS.n1 VSS 0.02951f
C4734 RX_BIAS.n2 VSS 0.02951f
C4735 RX_BIAS.n3 VSS 0.02951f
C4736 RX_BIAS.n4 VSS 0.02779f
C4737 RX_BIAS.n5 VSS 0.11903f
C4738 RX_BIAS.n6 VSS 0.01107f
C4739 RX_BIAS.n7 VSS 0.01376f
C4740 RX_BIAS.n8 VSS 0.01376f
C4741 RX_BIAS.n9 VSS 0.01107f
C4742 RX_BIAS.n10 VSS 0.27482f
C4743 RX_BIAS.n11 VSS 0.02779f
C4744 RX_BIAS.n12 VSS 0.02951f
C4745 RX_BIAS.n13 VSS 0.02951f
C4746 RX_BIAS.n14 VSS 0.02951f
C4747 RX_BIAS.n15 VSS 0.02779f
C4748 RX_BIAS.n16 VSS 0.10781f
C4749 RX_BIAS.n17 VSS 0.72566f
C4750 RX_BIAS.n18 VSS 0.71306f
C4751 RXP.t2 VSS 0.17644f
C4752 RXP.n0 VSS 0.53777f
C4753 RXP.n1 VSS 2.23071f
C4754 RXP.t3 VSS 0.03572f
C4755 RXP.t7 VSS 0.03572f
C4756 RXP.t1 VSS 0.03572f
C4757 RXP.t6 VSS 0.03572f
C4758 RXP.t0 VSS 0.03572f
C4759 RXP.t5 VSS 0.03515f
C4760 RXP.t4 VSS 0.05222f
C4761 RXP.n2 VSS 0.77274f
C4762 RXP.n3 VSS 0.46341f
C4763 RXP.n4 VSS 0.46341f
C4764 RXP.n5 VSS 0.46341f
C4765 RXP.n6 VSS 0.46341f
C4766 RXP.n7 VSS 0.42489f
C4767 RXN.t4 VSS 0.07002f
C4768 RXN.n0 VSS 0.21341f
C4769 RXN.n1 VSS 0.88522f
C4770 RXN.t3 VSS 0.01418f
C4771 RXN.t2 VSS 0.01418f
C4772 RXN.t1 VSS 0.01418f
C4773 RXN.t0 VSS 0.01418f
C4774 RXN.t6 VSS 0.01418f
C4775 RXN.t5 VSS 0.01395f
C4776 RXN.t7 VSS 0.02072f
C4777 RXN.n2 VSS 0.30665f
C4778 RXN.n3 VSS 0.1839f
C4779 RXN.n4 VSS 0.1839f
C4780 RXN.n5 VSS 0.1839f
C4781 RXN.n6 VSS 0.1839f
C4782 RXN.n7 VSS 0.16861f
C4783 TERM_EN6_N.n0 VSS 0.40332f
C4784 TERM_EN6_N.n1 VSS 1.74029f
C4785 TERM_EN6_N.n2 VSS 0.71327f
C4786 TERM_EN5_N.n0 VSS 0.41634f
C4787 TERM_EN5_N.n1 VSS 1.79643f
C4788 TERM_EN5_N.n2 VSS 0.73628f
C4789 TERM_EN4_N.n0 VSS 0.41634f
C4790 TERM_EN4_N.n1 VSS 1.79643f
C4791 TERM_EN4_N.n2 VSS 0.73628f
C4792 TERM_EN3_N.n0 VSS 0.41634f
C4793 TERM_EN3_N.n1 VSS 1.79643f
C4794 TERM_EN3_N.n2 VSS 0.73628f
C4795 TERM_EN2_N.n0 VSS 0.41634f
C4796 TERM_EN2_N.n1 VSS 1.79643f
C4797 TERM_EN2_N.n2 VSS 0.73628f
C4798 TERM_EN1_N.n0 VSS 0.41296f
C4799 TERM_EN1_N.n1 VSS 1.78189f
C4800 TERM_EN1_N.n2 VSS 0.73031f
C4801 TERM_EN0_N.n0 VSS 0.38663f
C4802 TERM_EN0_N.n1 VSS 1.66825f
C4803 TERM_EN0_N.n2 VSS 0.68374f
.ends
