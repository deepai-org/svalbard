* SPDX-License-Identifier: Apache-2.0
* Routed receive front end with fast converters through dual capture.
.include /src/lane_rx_frontend/lane_rx_frontend_fast.spice
.include /src/deserializer_split/deserializer_split.spice

.subckt lane_rx_capture RXP RXN TERM_EN0_N TERM_EN1_N TERM_EN2_N TERM_EN3_N
+ TERM_EN4_N TERM_EN5_N TERM_EN6_N VTHP VTHN RX_BIAS RX_BW_EN_N REST_BIAS
+ SAMP_CLK_P SAMP_CLK_N SAMP_BIAS E_SENSE_CLK E_REGEN_CLK E_REGEN_CLKB
+ E_CAPTURE_CLK E_CAPTURE_CLKB E_SENSE_BOOST O_SENSE_CLK O_REGEN_CLK
+ O_REGEN_CLKB O_CAPTURE_CLK O_CAPTURE_CLKB O_SENSE_BOOST VDD VSS
+ RX_RAWP RX_RAWN RX_RESTP RX_RESTN SAMP_E_P SAMP_E_N SAMP_O_P SAMP_O_N
+ FE_E_P FE_E_N FE_O_P FE_O_N EVEN_Q EVEN_QB ODD_Q ODD_QB
XFRONT RXP RXN TERM_EN0_N TERM_EN1_N TERM_EN2_N TERM_EN3_N TERM_EN4_N
+ TERM_EN5_N TERM_EN6_N VTHP VTHN RX_BIAS RX_BW_EN_N REST_BIAS
+ SAMP_CLK_P SAMP_CLK_N SAMP_BIAS E_SENSE_CLK E_REGEN_CLK E_REGEN_CLKB
+ E_CAPTURE_CLK E_CAPTURE_CLKB E_SENSE_BOOST O_SENSE_CLK O_REGEN_CLK
+ O_REGEN_CLKB O_CAPTURE_CLK O_CAPTURE_CLKB O_SENSE_BOOST VDD VSS
+ RX_RAWP RX_RAWN RX_RESTP RX_RESTN SAMP_E_P SAMP_E_N SAMP_O_P SAMP_O_N
+ FE_E_P FE_E_N FE_O_P FE_O_N lane_rx_frontend
XCAP FE_E_P FE_E_N FE_O_P FE_O_N E_CAPTURE_CLK E_CAPTURE_CLKB
+ O_CAPTURE_CLK O_CAPTURE_CLKB VDD VSS EVEN_Q EVEN_QB ODD_Q ODD_QB
+ deserializer_split_capture
.ends lane_rx_capture
