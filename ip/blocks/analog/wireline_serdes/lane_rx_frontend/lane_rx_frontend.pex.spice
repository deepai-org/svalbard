* PEX produced using /foss/tools/sak/sak-pex.sh with m=3 and s=1 (extresist threshold=0 mOhm, minres=1 mOhm, mindelay=0 ps)
* NGSPICE file created from lane_rx_frontend_pex.ext - technology: gf180mcuD

.subckt lane_rx_frontend_pex RXP RXN TERM_EN0_N TERM_EN1_N TERM_EN2_N TERM_EN3_N TERM_EN4_N
+ TERM_EN5_N TERM_EN6_N VTHP VTHN RX_BIAS RX_BW_EN_N REST_BIAS SAMP_CLK_P SAMP_CLK_N
+ SAMP_BIAS E_SENSE_CLK E_REGEN_CLK E_REGEN_CLKB E_CAPTURE_CLK E_CAPTURE_CLKB E_SENSE_BOOST
+ O_SENSE_CLK O_REGEN_CLK O_REGEN_CLKB O_CAPTURE_CLK O_CAPTURE_CLKB O_SENSE_BOOST
+ VDD VSS RX_RAWP RX_RAWN RX_RESTP RX_RESTN SAMP_E_P SAMP_E_N SAMP_O_P SAMP_O_N FE_E_P
+ FE_E_N FE_O_P FE_O_N
X0 XFE_O.XP.t3 XFE_O.SB.t13 XFE_O.NREGEN.t6 VSS.t87 nfet_03v3 ad=2.08p pd=8.52u as=2.08p ps=8.52u w=8u l=0.28u
X1 VSS.t173 RX_BIAS.t4 a_2148_n500.t0 VSS.t169 nfet_03v3 ad=2.6p pd=10.52u as=4.4p ps=20.88u w=10u l=0.28u
X2 a_n10800_n17972.t1 TERM_EN3_N.t2 VSS.t32 VSS.t0 nfet_03v3 ad=0.44p pd=2.88u as=0.44p ps=2.88u w=1u l=0.28u
X3 a_12148_44200.t2 SAMP_O_N.t6 SAMP_O_P.t1 VSS.t107 nfet_03v3 ad=1.56p pd=6.52u as=2.64p ps=12.88u w=6u l=0.28u
X4 XFE_E.VREGP.t14 XFE_E.XN.t51 XFE_E.XP.t11 VDD.t98 pfet_03v3 ad=2.08p pd=8.52u as=2.08p ps=8.52u w=8u l=0.28u
X5 VDD.t329 XFE_E.XP.t45 XFE_E.SXP.t7 VDD.t328 pfet_03v3 ad=2.08p pd=8.52u as=2.08p ps=8.52u w=8u l=0.28u
X6 XFE_O.SXP.t4 XFE_O.XP.t46 VDD.t379 VDD.t378 pfet_03v3 ad=2.08p pd=8.52u as=2.08p ps=8.52u w=8u l=0.28u
X7 FE_E_P.t2 XFE_E.BN.t18 VDD.t122 VDD.t121 pfet_03v3 ad=2.08p pd=8.52u as=2.08p ps=8.52u w=8u l=0.28u
X8 VDD.t215 XFE_E.BP.t19 FE_E_N.t7 VDD.t214 pfet_03v3 ad=2.08p pd=8.52u as=2.08p ps=8.52u w=8u l=0.28u
X9 XFE_E.VREGP.t5 E_REGEN_CLKB.t2 VDD.t63 VDD.t62 pfet_03v3 ad=2.08p pd=8.52u as=2.08p ps=8.52u w=8u l=0.28u
X10 VDD.t181 XFE_O.BP.t17 FE_O_P.t6 VDD.t180 pfet_03v3 ad=2.08p pd=8.52u as=2.08p ps=8.52u w=8u l=0.28u
X11 VDD.t245 O_REGEN_CLK.t17 XFE_O.XN.t9 VDD.t244 pfet_03v3 ad=2.08p pd=8.52u as=2.08p ps=8.52u w=8u l=0.28u
X12 a_n7157_n21700.t2 a_n10800_n21572.t3 a_n6400_n21652.t1 VSS.t219 nfet_03v3 ad=4.4p pd=20.88u as=2.6p ps=10.52u w=10u l=0.28u
X13 SAMP_E_P.t4 RX_RESTN.t5 a_948_44200.t3 VSS.t289 nfet_03v3 ad=2.64p pd=12.88u as=1.56p ps=6.52u w=6u l=0.28u
X14 XFE_O.NREGEN.t3 XFE_O.SB.t10 XFE_O.XP.t2 VSS.t81 nfet_03v3 ad=2.08p pd=8.52u as=2.08p ps=8.52u w=8u l=0.28u
X15 VDD.t272 E_SENSE_CLK.t3 XFE_E.SA.t2 VDD.t159 pfet_03v3 ad=2.08p pd=8.52u as=3.52p ps=16.88u w=8u l=0.28u
X16 XFE_E.VREGN.t7 E_REGEN_CLKB.t8 VDD.t53 VDD.t52 pfet_03v3 ad=3.52p pd=16.88u as=2.08p ps=8.52u w=8u l=0.28u
X17 a_2148_n500.t8 a_n6572_3500.t7 RX_RAWP.t2 VSS.t88 nfet_03v3 ad=1.3p pd=5.52u as=2.2p ps=10.88u w=5u l=0.28u
X18 XFE_O.SXN.t2 XFE_O.XN.t38 VSS.t86 VSS.t85 nfet_03v3 ad=3.52p pd=16.88u as=2.08p ps=8.52u w=8u l=0.28u
X19 VDD.t170 E_REGEN_CLK.t13 XFE_E.XP.t24 VDD.t169 pfet_03v3 ad=2.08p pd=8.52u as=2.08p ps=8.52u w=8u l=0.28u
X20 VDD.t278 XFE_O.XN.t47 XFE_O.SXN.t7 VDD.t277 pfet_03v3 ad=2.08p pd=8.52u as=2.08p ps=8.52u w=8u l=0.28u
X21 VDD.t174 E_REGEN_CLK.t9 XFE_E.NREGEN.t16 VDD.t173 pfet_03v3 ad=2.08p pd=8.52u as=3.52p ps=16.88u w=8u l=0.28u
X22 XFE_E.VREGN.t10 XFE_E.XP.t55 XFE_E.XN.t28 VDD.t303 pfet_03v3 ad=2.08p pd=8.52u as=2.08p ps=8.52u w=8u l=0.28u
X23 XFE_E.XP.t30 XFE_E.XN.t54 XFE_E.VREGP.t11 VDD.t213 pfet_03v3 ad=2.08p pd=8.52u as=2.08p ps=8.52u w=8u l=0.28u
X24 a_n5052_2600.t2 VTHN.t1 a_n3600_5641.t2 VSS.t138 nfet_03v3 ad=0.52p pd=2.52u as=0.88p ps=4.88u w=2u l=0.28u
X25 VSS.t187 XFE_E.SXN.t15 XFE_E.BN.t6 VSS.t186 nfet_03v3 ad=2.08p pd=8.52u as=2.08p ps=8.52u w=8u l=0.28u
X26 VDD.t381 XFE_O.XP.t43 XFE_O.SXP.t8 VDD.t380 pfet_03v3 ad=2.08p pd=8.52u as=2.08p ps=8.52u w=8u l=0.28u
X27 VSS.t195 O_REGEN_CLK.t7 XFE_O.NREGEN.t20 VSS.t194 nfet_03v3 ad=2.08p pd=8.52u as=3.52p ps=16.88u w=8u l=0.28u
X28 XFE_O.BN.t1 XFE_O.SXN.t20 VDD.t116 VDD.t115 pfet_03v3 ad=3.52p pd=16.88u as=2.08p ps=8.52u w=8u l=0.28u
X29 RX_RESTN.t1 a_600_22678.t3 a_n852_28800.t4 VSS.t76 nfet_03v3 ad=4.4p pd=20.88u as=2.6p ps=10.52u w=10u l=0.28u
X30 FE_E_N.t2 XFE_E.BP.t16 VDD.t77 VDD.t76 pfet_03v3 ad=3.52p pd=16.88u as=2.08p ps=8.52u w=8u l=0.28u
X31 VDD.t57 E_REGEN_CLKB.t5 XFE_E.VREGP.t2 VDD.t56 pfet_03v3 ad=2.08p pd=8.52u as=2.08p ps=8.52u w=8u l=0.28u
X32 VSS.t160 RX_BIAS.t13 a_n5052_2600.t4 VSS.t159 nfet_03v3 ad=0.52p pd=2.52u as=0.88p ps=4.88u w=2u l=0.28u
X33 FE_E_P.t9 XFE_E.BN.t12 VSS.t234 VSS.t233 nfet_03v3 ad=2.08p pd=8.52u as=2.08p ps=8.52u w=8u l=0.28u
X34 a_n6400_n18052.t4 a_n10800_n17972.t2 a_n7300_n18100.t4 VSS.t284 nfet_03v3 ad=2.6p pd=10.52u as=4.4p ps=20.88u w=10u l=0.28u
X35 VDD.t9 O_REGEN_CLKB.t13 XFE_O.VREGP.t2 VDD.t8 pfet_03v3 ad=2.08p pd=8.52u as=2.08p ps=8.52u w=8u l=0.28u
X36 XFE_E.NREGEN.t30 XFE_E.XN.t36 XFE_E.XP.t33 VSS.t336 nfet_03v3 ad=2.08p pd=8.52u as=2.08p ps=8.52u w=8u l=0.28u
X37 a_600_22678.t2 RX_RAWN.t4 a_n852_19400.t7 VSS.t76 nfet_03v3 ad=4.4p pd=20.88u as=2.6p ps=10.52u w=10u l=0.28u
X38 XFE_E.SXN.t9 XFE_E.XN.t38 VSS.t191 VSS.t190 nfet_03v3 ad=3.52p pd=16.88u as=2.08p ps=8.52u w=8u l=0.28u
X39 XFE_E.SB.t6 VSS.t372 VDD.t290 VDD.t289 pfet_03v3 ad=3.52p pd=16.88u as=3.52p ps=16.88u w=8u l=0.28u
X40 VSS.t20 XFE_O.SXP.t13 XFE_O.BP.t8 VSS.t19 nfet_03v3 ad=2.08p pd=8.52u as=2.08p ps=8.52u w=8u l=0.28u
X41 XFE_E.BN.t3 XFE_E.SXN.t18 VSS.t122 VSS.t121 nfet_03v3 ad=2.08p pd=8.52u as=2.08p ps=8.52u w=8u l=0.28u
X42 a_n852_19400.t5 REST_BIAS.t0 VSS.t267 VSS.t262 nfet_03v3 ad=5.28p pd=24.88u as=3.12p ps=12.52u w=12u l=0.28u
X43 XFE_O.VREGN.t3 O_REGEN_CLKB.t4 VDD.t25 VDD.t24 pfet_03v3 ad=2.08p pd=8.52u as=2.08p ps=8.52u w=8u l=0.28u
X44 a_n6400_n12652.t2 RXN.t5 VSS.t158 ppolyf_u r_width=1u r_length=1u
X45 VSS.t128 E_REGEN_CLK.t7 XFE_E.NREGEN.t18 VSS.t127 nfet_03v3 ad=2.08p pd=8.52u as=3.52p ps=16.88u w=8u l=0.28u
X46 RXP.t7 a_n7157_n23500.t4 VSS.t98 ppolyf_u r_width=1u r_length=2.43u
X47 VSS.t297 XFE_E.XP.t39 XFE_E.SXP.t1 VSS.t296 nfet_03v3 ad=2.08p pd=8.52u as=2.08p ps=8.52u w=8u l=0.28u
X48 a_n5052_2600.t5 RX_BIAS.t12 VSS.t161 VSS.t159 nfet_03v3 ad=0.52p pd=2.52u as=0.52p ps=2.52u w=2u l=0.28u
X49 XFE_O.SXP.t6 XFE_O.XP.t40 VSS.t354 VSS.t353 nfet_03v3 ad=2.08p pd=8.52u as=2.08p ps=8.52u w=8u l=0.28u
X50 XFE_E.SXP.t8 XFE_E.XP.t46 VDD.t351 VDD.t350 pfet_03v3 ad=2.08p pd=8.52u as=2.08p ps=8.52u w=8u l=0.28u
X51 VDD.t142 E_REGEN_CLK.t29 XFE_E.XN.t12 VDD.t141 pfet_03v3 ad=2.08p pd=8.52u as=2.08p ps=8.52u w=8u l=0.28u
X52 XFE_O.XN.t1 XFE_O.SA.t7 XFE_O.NREGEN.t4 VSS.t82 nfet_03v3 ad=3.52p pd=16.88u as=2.08p ps=8.52u w=8u l=0.28u
X53 a_n852_28800.t3 REST_BIAS.t4 VSS.t263 VSS.t262 nfet_03v3 ad=5.28p pd=24.88u as=3.12p ps=12.52u w=12u l=0.28u
X54 FE_O_P.t3 XFE_O.BP.t14 VSS.t102 VSS.t101 nfet_03v3 ad=2.08p pd=8.52u as=2.08p ps=8.52u w=8u l=0.28u
X55 VDD.t33 O_REGEN_CLKB.t1 XFE_O.VREGN.t6 VDD.t32 pfet_03v3 ad=2.08p pd=8.52u as=2.08p ps=8.52u w=8u l=0.28u
X56 VSS.t311 XFE_O.XN.t41 XFE_O.SXN.t9 VSS.t310 nfet_03v3 ad=2.08p pd=8.52u as=3.52p ps=16.88u w=8u l=0.28u
X57 XFE_E.XN.t33 XFE_E.XP.t52 XFE_E.VREGN.t13 VDD.t300 pfet_03v3 ad=2.08p pd=8.52u as=2.08p ps=8.52u w=8u l=0.28u
X58 XFE_E.NTAIL.t7 SAMP_E_P.t8 XFE_E.SB.t0 VSS.t69 nfet_03v3 ad=2.08p pd=8.52u as=3.52p ps=16.88u w=8u l=0.28u
X59 a_n10800_n23372.t1 TERM_EN0_N.t2 VSS.t67 VSS.t0 nfet_03v3 ad=0.44p pd=2.88u as=0.44p ps=2.88u w=1u l=0.28u
X60 XFE_E.NREGEN.t13 XFE_E.SB.t10 XFE_E.XP.t13 VSS.t91 nfet_03v3 ad=2.08p pd=8.52u as=2.08p ps=8.52u w=8u l=0.28u
X61 XFE_E.BN.t9 XFE_E.SXN.t12 VSS.t149 VSS.t148 nfet_03v3 ad=3.52p pd=16.88u as=2.08p ps=8.52u w=8u l=0.28u
X62 XFE_E.BN.t1 XFE_E.SXN.t20 VDD.t200 VDD.t199 pfet_03v3 ad=3.52p pd=16.88u as=2.08p ps=8.52u w=8u l=0.28u
X63 a_n7300_n14500.t1 TERM_EN5_N.t1 a_n6400_n14452.t0 VDD.t113 pfet_03v3 ad=4.4p pd=20.88u as=2.6p ps=10.52u w=10u l=0.28u
X64 XFE_E.XN.t9 E_REGEN_CLK.t32 VDD.t136 VDD.t135 pfet_03v3 ad=2.08p pd=8.52u as=2.08p ps=8.52u w=8u l=0.28u
X65 VSS.t142 XFE_O.BP.t11 FE_O_P.t9 VSS.t141 nfet_03v3 ad=2.08p pd=8.52u as=2.08p ps=8.52u w=8u l=0.28u
X66 a_10548_44200.t1 SAMP_CLK_N.t0 a_11748_41600.t1 VSS.t271 nfet_03v3 ad=3.52p pd=16.88u as=2.08p ps=8.52u w=8u l=0.28u
X67 FE_E_N.t0 XFE_E.BP.t14 VSS.t29 VSS.t28 nfet_03v3 ad=2.08p pd=8.52u as=2.08p ps=8.52u w=8u l=0.28u
X68 XFE_E.NTAIL.t11 E_SENSE_CLK.t0 VSS.t238 VSS.t237 nfet_03v3 ad=3.52p pd=16.88u as=2.08p ps=8.52u w=8u l=0.28u
X69 VDD.t84 XFE_E.XN.t49 XFE_E.SXN.t2 VDD.t83 pfet_03v3 ad=2.08p pd=8.52u as=3.52p ps=16.88u w=8u l=0.28u
X70 XFE_O.NREGEN.t17 O_REGEN_CLK.t10 VDD.t255 VDD.t254 pfet_03v3 ad=3.52p pd=16.88u as=2.08p ps=8.52u w=8u l=0.28u
X71 XFE_E.XP.t10 XFE_E.SB.t13 XFE_E.NREGEN.t11 VSS.t73 nfet_03v3 ad=2.08p pd=8.52u as=2.08p ps=8.52u w=8u l=0.28u
X72 VDD.t247 O_REGEN_CLK.t15 XFE_O.XN.t11 VDD.t211 pfet_03v3 ad=2.08p pd=8.52u as=2.08p ps=8.52u w=8u l=0.28u
X73 XFE_O.XN.t3 XFE_O.SA.t13 XFE_O.NREGEN.t12 VSS.t156 nfet_03v3 ad=2.08p pd=8.52u as=2.08p ps=8.52u w=8u l=0.28u
X74 XFE_O.BP.t5 XFE_O.SXP.t16 VSS.t57 VSS.t56 nfet_03v3 ad=2.08p pd=8.52u as=2.08p ps=8.52u w=8u l=0.28u
X75 XFE_O.NREGEN.t9 XFE_O.SB.t8 XFE_O.XP.t5 VSS.t147 nfet_03v3 ad=2.08p pd=8.52u as=2.08p ps=8.52u w=8u l=0.28u
X76 a_n5052_n1000.t3 RX_BIAS.t8 VSS.t166 VSS.t165 nfet_03v3 ad=2.6p pd=10.52u as=2.6p ps=10.52u w=10u l=0.28u
X77 a_n10800_n12572.t0 TERM_EN6_N.t3 VDD.t1 VDD.t0 pfet_03v3 ad=0.88p pd=4.88u as=0.88p ps=4.88u w=2u l=0.28u
X78 VDD.t186 XFE_O.XN.t45 XFE_O.SXN.t3 VDD.t185 pfet_03v3 ad=2.08p pd=8.52u as=2.08p ps=8.52u w=8u l=0.28u
X79 XFE_E.VREGN.t3 E_REGEN_CLKB.t12 VDD.t37 VDD.t36 pfet_03v3 ad=2.08p pd=8.52u as=2.08p ps=8.52u w=8u l=0.28u
X80 XFE_E.XP.t32 XFE_E.XN.t56 XFE_E.VREGP.t9 VDD.t294 pfet_03v3 ad=2.08p pd=8.52u as=2.08p ps=8.52u w=8u l=0.28u
X81 XFE_O.NTAIL.t1 SAMP_O_P.t8 XFE_O.SA.t0 VSS.t34 nfet_03v3 ad=2.08p pd=8.52u as=3.52p ps=16.88u w=8u l=0.28u
X82 VDD.t108 XFE_E.BN.t23 FE_E_P.t1 VDD.t107 pfet_03v3 ad=2.08p pd=8.52u as=3.52p ps=16.88u w=8u l=0.28u
X83 a_n7300_n18100.t0 TERM_EN3_N.t1 a_n6400_n18052.t0 VDD.t80 pfet_03v3 ad=4.4p pd=20.88u as=2.6p ps=10.52u w=10u l=0.28u
X84 XFE_E.NREGEN.t12 XFE_E.SA.t14 XFE_E.XN.t5 VSS.t83 nfet_03v3 ad=2.08p pd=8.52u as=3.52p ps=16.88u w=8u l=0.28u
X85 RX_RAWP.t3 RX_BW_EN_N.t1 a_484_3500.t1 VDD.t397 pfet_03v3 ad=2.2p pd=10.88u as=2.2p ps=10.88u w=5u l=0.28u
X86 a_n6400_n16252.t0 RXN.t2 VSS.t64 ppolyf_u r_width=1u r_length=1u
X87 XFE_O.BN.t6 XFE_O.SXN.t16 VSS.t329 VSS.t328 nfet_03v3 ad=2.08p pd=8.52u as=2.08p ps=8.52u w=8u l=0.28u
X88 XFE_E.SXP.t2 XFE_E.XP.t40 VSS.t299 VSS.t298 nfet_03v3 ad=2.08p pd=8.52u as=2.08p ps=8.52u w=8u l=0.28u
X89 VDD.t49 E_REGEN_CLKB.t7 XFE_E.VREGP.t0 VDD.t48 pfet_03v3 ad=2.08p pd=8.52u as=3.52p ps=16.88u w=8u l=0.28u
X90 a_n6400_n23452.t4 a_n10800_n23372.t2 a_n7157_n23500.t3 VSS.t247 nfet_03v3 ad=2.6p pd=10.52u as=4.4p ps=20.88u w=10u l=0.28u
X91 XFE_O.XN.t14 O_REGEN_CLK.t12 VDD.t253 VDD.t252 pfet_03v3 ad=3.52p pd=16.88u as=2.08p ps=8.52u w=8u l=0.28u
X92 XFE_O.NREGEN.t14 XFE_O.SA.t10 XFE_O.XN.t5 VSS.t177 nfet_03v3 ad=2.08p pd=8.52u as=2.08p ps=8.52u w=8u l=0.28u
X93 VDD.t341 XFE_O.BN.t19 FE_O_N.t3 VDD.t340 pfet_03v3 ad=2.08p pd=8.52u as=2.08p ps=8.52u w=8u l=0.28u
X94 XFE_E.XP.t19 E_REGEN_CLK.t18 VDD.t156 VDD.t155 pfet_03v3 ad=2.08p pd=8.52u as=2.08p ps=8.52u w=8u l=0.28u
X95 VDD.t13 O_REGEN_CLKB.t11 XFE_O.VREGP.t4 VDD.t12 pfet_03v3 ad=2.08p pd=8.52u as=2.08p ps=8.52u w=8u l=0.28u
X96 XFE_O.XN.t15 O_REGEN_CLK.t27 XFE_O.XP.t14 VDD.t234 pfet_03v3 ad=2.08p pd=8.52u as=3.52p ps=16.88u w=8u l=0.28u
X97 RX_RAWN.t1 a_n3600_5641.t6 a_2148_n500.t5 VSS.t88 nfet_03v3 ad=2.2p pd=10.88u as=1.3p ps=5.52u w=5u l=0.28u
X98 XFE_O.SXN.t10 XFE_O.XN.t42 VDD.t319 VDD.t318 pfet_03v3 ad=3.52p pd=16.88u as=2.08p ps=8.52u w=8u l=0.28u
X99 a_n1900_5958.t1 RX_BW_EN_N.t2 a_n3600_5641.t4 VDD.t396 pfet_03v3 ad=2.2p pd=10.88u as=2.2p ps=10.88u w=5u l=0.28u
X100 a_n6400_n12652.t0 TERM_EN6_N.t0 a_n7300_n12700.t1 VDD.t3 pfet_03v3 ad=2.6p pd=10.52u as=4.4p ps=20.88u w=10u l=0.28u
X101 VDD.t284 VSS.t369 XFE_O.SB.t6 VDD.t283 pfet_03v3 ad=3.52p pd=16.88u as=3.52p ps=16.88u w=8u l=0.28u
X102 XFE_O.NREGEN.t31 XFE_O.XP.t37 XFE_O.XN.t32 VSS.t355 nfet_03v3 ad=2.08p pd=8.52u as=3.52p ps=16.88u w=8u l=0.28u
X103 XFE_E.XP.t1 XFE_E.SB.t7 XFE_E.NREGEN.t2 VSS.t18 nfet_03v3 ad=3.52p pd=16.88u as=2.08p ps=8.52u w=8u l=0.28u
X104 VSS.t223 XFE_O.SXN.t13 XFE_O.BN.t3 VSS.t222 nfet_03v3 ad=2.08p pd=8.52u as=2.08p ps=8.52u w=8u l=0.28u
X105 VDD.t270 E_SENSE_CLK.t7 XFE_E.SB.t2 VDD.t135 pfet_03v3 ad=2.08p pd=8.52u as=3.52p ps=16.88u w=8u l=0.28u
X106 SAMP_E_N.t4 RX_RESTP.t5 a_948_44200.t1 VSS.t274 nfet_03v3 ad=2.64p pd=12.88u as=1.56p ps=6.52u w=6u l=0.28u
X107 RXP.t3 a_n7300_n12700.t2 VSS.t98 ppolyf_u r_width=1u r_length=1u
X108 FE_O_N.t8 XFE_O.BN.t16 VDD.t347 VDD.t346 pfet_03v3 ad=3.52p pd=16.88u as=2.08p ps=8.52u w=8u l=0.28u
X109 XFE_E.XP.t8 XFE_E.XN.t50 XFE_E.VREGP.t15 VDD.t86 pfet_03v3 ad=3.52p pd=16.88u as=2.08p ps=8.52u w=8u l=0.28u
X110 a_n6400_n19852.t0 RXN.t4 VSS.t145 ppolyf_u r_width=1u r_length=1u
X111 XFE_E.SXP.t6 XFE_E.XP.t44 VDD.t327 VDD.t326 pfet_03v3 ad=2.08p pd=8.52u as=2.08p ps=8.52u w=8u l=0.28u
X112 XFE_O.VREGP.t7 O_REGEN_CLKB.t8 VDD.t19 VDD.t18 pfet_03v3 ad=3.52p pd=16.88u as=2.08p ps=8.52u w=8u l=0.28u
X113 VSS.t52 XFE_E.SXP.t13 XFE_E.BP.t1 VSS.t51 nfet_03v3 ad=2.08p pd=8.52u as=2.08p ps=8.52u w=8u l=0.28u
X114 a_n6572_3500.t5 RX_BW_EN_N.t3 a_n6716_3500.t1 VDD.t395 pfet_03v3 ad=2.2p pd=10.88u as=2.2p ps=10.88u w=5u l=0.28u
X115 SAMP_O_N.t3 SAMP_O_P.t5 a_12148_44200.t1 VSS.t37 nfet_03v3 ad=2.64p pd=12.88u as=1.56p ps=6.52u w=6u l=0.28u
X116 XFE_O.SB.t3 O_SENSE_CLK.t2 VDD.t212 VDD.t211 pfet_03v3 ad=3.52p pd=16.88u as=2.08p ps=8.52u w=8u l=0.28u
X117 VSS.t344 XFE_O.BN.t11 FE_O_N.t11 VSS.t343 nfet_03v3 ad=2.08p pd=8.52u as=2.08p ps=8.52u w=8u l=0.28u
X118 XFE_E.XN.t14 E_REGEN_CLK.t27 XFE_E.XP.t14 VDD.t145 pfet_03v3 ad=2.08p pd=8.52u as=3.52p ps=16.88u w=8u l=0.28u
X119 XFE_O.XN.t8 O_REGEN_CLK.t18 VDD.t243 VDD.t242 pfet_03v3 ad=2.08p pd=8.52u as=2.08p ps=8.52u w=8u l=0.28u
X120 XFE_O.XP.t1 XFE_O.SB.t11 XFE_O.NREGEN.t2 VSS.t63 nfet_03v3 ad=2.08p pd=8.52u as=2.08p ps=8.52u w=8u l=0.28u
X121 VSS.t174 RX_BIAS.t2 a_2148_n500.t2 VSS.t169 nfet_03v3 ad=2.6p pd=10.52u as=2.6p ps=10.52u w=10u l=0.28u
X122 VDD.t261 SAMP_O_P.t2 VSS.t220 ppolyf_u r_width=2u r_length=5u
X123 XFE_O.NTAIL.t7 O_SENSE_BOOST.t4 VSS.t251 VSS.t198 nfet_03v3 ad=2.08p pd=8.52u as=2.08p ps=8.52u w=8u l=0.28u
X124 VDD.t194 XFE_O.SXP.t21 XFE_O.BP.t0 VDD.t193 pfet_03v3 ad=2.08p pd=8.52u as=3.52p ps=16.88u w=8u l=0.28u
X125 XFE_E.XP.t25 E_REGEN_CLK.t12 VDD.t172 VDD.t171 pfet_03v3 ad=3.52p pd=16.88u as=2.08p ps=8.52u w=8u l=0.28u
X126 VSS.t46 XFE_O.XN.t39 XFE_O.SXN.t0 VSS.t45 nfet_03v3 ad=2.08p pd=8.52u as=2.08p ps=8.52u w=8u l=0.28u
X127 FE_E_N.t12 XFE_E.BP.t22 VDD.t392 VDD.t391 pfet_03v3 ad=2.08p pd=8.52u as=2.08p ps=8.52u w=8u l=0.28u
X128 XFE_O.SXN.t8 XFE_O.XN.t48 VDD.t280 VDD.t279 pfet_03v3 ad=2.08p pd=8.52u as=2.08p ps=8.52u w=8u l=0.28u
X129 XFE_E.VREGP.t12 XFE_E.XN.t53 XFE_E.XP.t9 VDD.t89 pfet_03v3 ad=2.08p pd=8.52u as=2.08p ps=8.52u w=8u l=0.28u
X130 XFE_E.NREGEN.t17 E_REGEN_CLK.t8 VDD.t176 VDD.t175 pfet_03v3 ad=3.52p pd=16.88u as=2.08p ps=8.52u w=8u l=0.28u
X131 a_n10800_n16172.t0 TERM_EN4_N.t3 VDD.t297 VDD.t296 pfet_03v3 ad=0.88p pd=4.88u as=0.88p ps=4.88u w=2u l=0.28u
X132 XFE_O.SB.t1 SAMP_O_N.t7 XFE_O.NTAIL.t2 VSS.t106 nfet_03v3 ad=3.52p pd=16.88u as=2.08p ps=8.52u w=8u l=0.28u
X133 XFE_E.NTAIL.t9 SAMP_E_N.t8 XFE_E.SA.t0 VSS.t208 nfet_03v3 ad=2.08p pd=8.52u as=3.52p ps=16.88u w=8u l=0.28u
X134 XFE_E.BP.t5 XFE_E.SXP.t16 VSS.t95 VSS.t94 nfet_03v3 ad=2.08p pd=8.52u as=2.08p ps=8.52u w=8u l=0.28u
X135 a_n852_28800.t6 a_600_22678.t4 RX_RESTN.t2 VSS.t78 nfet_03v3 ad=2.6p pd=10.52u as=4.4p ps=20.88u w=10u l=0.28u
X136 VDD.t118 XFE_O.SXN.t21 XFE_O.BN.t2 VDD.t117 pfet_03v3 ad=2.08p pd=8.52u as=3.52p ps=16.88u w=8u l=0.28u
X137 VDD.t264 XFE_E.BP.t17 FE_E_N.t9 VDD.t263 pfet_03v3 ad=2.08p pd=8.52u as=2.08p ps=8.52u w=8u l=0.28u
X138 XFE_E.XN.t7 E_REGEN_CLK.t34 VDD.t132 VDD.t131 pfet_03v3 ad=2.08p pd=8.52u as=2.08p ps=8.52u w=8u l=0.28u
X139 XFE_O.VREGP.t8 XFE_O.XN.t57 XFE_O.XP.t26 VDD.t260 pfet_03v3 ad=2.08p pd=8.52u as=3.52p ps=16.88u w=8u l=0.28u
X140 FE_O_N.t0 XFE_O.BN.t22 VDD.t331 VDD.t330 pfet_03v3 ad=2.08p pd=8.52u as=2.08p ps=8.52u w=8u l=0.28u
X141 VSS.t254 O_SENSE_BOOST.t1 XFE_O.NTAIL.t10 VSS.t202 nfet_03v3 ad=2.08p pd=8.52u as=2.08p ps=8.52u w=8u l=0.28u
X142 VSS.t232 XFE_E.BN.t11 FE_E_P.t8 VSS.t231 nfet_03v3 ad=2.08p pd=8.52u as=2.08p ps=8.52u w=8u l=0.28u
X143 XFE_E.VREGN.t5 E_REGEN_CLKB.t10 VDD.t47 VDD.t46 pfet_03v3 ad=2.08p pd=8.52u as=2.08p ps=8.52u w=8u l=0.28u
X144 XFE_O.VREGP.t1 O_REGEN_CLKB.t14 VDD.t5 VDD.t4 pfet_03v3 ad=2.08p pd=8.52u as=2.08p ps=8.52u w=8u l=0.28u
X145 VDD.t166 E_REGEN_CLK.t15 XFE_E.XP.t22 VDD.t165 pfet_03v3 ad=2.08p pd=8.52u as=2.08p ps=8.52u w=8u l=0.28u
X146 XFE_E.XP.t2 XFE_E.XN.t35 XFE_E.NREGEN.t3 VSS.t27 nfet_03v3 ad=3.52p pd=16.88u as=2.08p ps=8.52u w=8u l=0.28u
X147 a_n852_19400.t6 RX_RAWN.t5 a_600_22678.t1 VSS.t78 nfet_03v3 ad=2.6p pd=10.52u as=4.4p ps=20.88u w=10u l=0.28u
X148 XFE_E.VREGN.t8 XFE_E.XP.t57 XFE_E.XN.t29 VDD.t305 pfet_03v3 ad=2.08p pd=8.52u as=3.52p ps=16.88u w=8u l=0.28u
X149 VSS.t181 O_SENSE_CLK.t1 XFE_O.NTAIL.t4 VSS.t180 nfet_03v3 ad=2.08p pd=8.52u as=3.52p ps=16.88u w=8u l=0.28u
X150 VSS.t120 XFE_E.SXN.t17 XFE_E.BN.t4 VSS.t119 nfet_03v3 ad=2.08p pd=8.52u as=2.08p ps=8.52u w=8u l=0.28u
X151 VSS.t199 O_REGEN_CLK.t5 XFE_O.NREGEN.t22 VSS.t198 nfet_03v3 ad=2.08p pd=8.52u as=2.08p ps=8.52u w=8u l=0.28u
X152 VDD.t221 O_REGEN_CLK.t35 XFE_O.XP.t6 VDD.t220 pfet_03v3 ad=2.08p pd=8.52u as=3.52p ps=16.88u w=8u l=0.28u
X153 a_n6400_n16252.t3 TERM_EN4_N.t0 a_n7300_n16300.t3 VDD.t299 pfet_03v3 ad=2.6p pd=10.52u as=4.4p ps=20.88u w=10u l=0.28u
X154 a_2548_44200.t5 SAMP_CLK_N.t2 a_2148_41600.t1 VSS.t269 nfet_03v3 ad=3.52p pd=16.88u as=2.08p ps=8.52u w=8u l=0.28u
X155 a_n10800_n19772.t0 TERM_EN2_N.t3 VDD.t309 VDD.t308 pfet_03v3 ad=0.88p pd=4.88u as=0.88p ps=4.88u w=2u l=0.28u
X156 XFE_E.SXP.t0 XFE_E.XP.t38 VSS.t295 VSS.t294 nfet_03v3 ad=3.52p pd=16.88u as=2.08p ps=8.52u w=8u l=0.28u
X157 FE_E_P.t5 XFE_E.BN.t14 VSS.t215 VSS.t214 nfet_03v3 ad=2.08p pd=8.52u as=2.08p ps=8.52u w=8u l=0.28u
X158 a_11748_41600.t5 SAMP_BIAS.t2 VSS.t325 VSS.t324 nfet_03v3 ad=2.6p pd=10.52u as=2.6p ps=10.52u w=10u l=0.28u
X159 RXP.t2 a_n7300_n16300.t0 VSS.t98 ppolyf_u r_width=1u r_length=1u
X160 XFE_E.XN.t13 E_REGEN_CLK.t28 VDD.t144 VDD.t143 pfet_03v3 ad=3.52p pd=16.88u as=2.08p ps=8.52u w=8u l=0.28u
X161 XFE_O.NREGEN.t19 O_REGEN_CLK.t8 VDD.t259 VDD.t258 pfet_03v3 ad=3.52p pd=16.88u as=2.08p ps=8.52u w=8u l=0.28u
X162 FE_O_N.t6 XFE_O.BN.t14 VSS.t338 VSS.t337 nfet_03v3 ad=2.08p pd=8.52u as=2.08p ps=8.52u w=8u l=0.28u
X163 XFE_O.NREGEN.t15 XFE_O.SA.t8 XFE_O.XN.t6 VSS.t179 nfet_03v3 ad=2.08p pd=8.52u as=2.08p ps=8.52u w=8u l=0.28u
X164 XFE_O.NREGEN.t25 O_REGEN_CLK.t2 VSS.t203 VSS.t202 nfet_03v3 ad=2.08p pd=8.52u as=2.08p ps=8.52u w=8u l=0.28u
X165 XFE_O.NREGEN.t5 XFE_O.XN.t37 XFE_O.XP.t31 VSS.t84 nfet_03v3 ad=2.08p pd=8.52u as=3.52p ps=16.88u w=8u l=0.28u
X166 VSS.t104 XFE_O.BP.t15 FE_O_P.t4 VSS.t103 nfet_03v3 ad=2.08p pd=8.52u as=3.52p ps=16.88u w=8u l=0.28u
X167 a_n5052_2600.t7 RX_BIAS.t10 VSS.t164 VSS.t162 nfet_03v3 ad=0.88p pd=4.88u as=0.52p ps=2.52u w=2u l=0.28u
X168 a_n6572_3500.t4 RXP.t8 a_n5052_n1000.t7 VSS.t334 nfet_03v3 ad=4.4p pd=20.88u as=2.6p ps=10.52u w=10u l=0.28u
X169 a_n6400_n19852.t3 TERM_EN2_N.t0 a_n7300_n19900.t3 VDD.t311 pfet_03v3 ad=2.6p pd=10.52u as=4.4p ps=20.88u w=10u l=0.28u
X170 a_n3600_5641.t3 VTHN.t0 a_n5052_2600.t3 VSS.t138 nfet_03v3 ad=0.88p pd=4.88u as=0.52p ps=2.52u w=2u l=0.28u
X171 XFE_E.SB.t1 SAMP_E_P.t7 XFE_E.NTAIL.t6 VSS.t70 nfet_03v3 ad=3.52p pd=16.88u as=2.08p ps=8.52u w=8u l=0.28u
X172 XFE_O.NREGEN.t32 XFE_O.XP.t35 XFE_O.XN.t33 VSS.t360 nfet_03v3 ad=3.52p pd=16.88u as=2.08p ps=8.52u w=8u l=0.28u
X173 XFE_E.XP.t3 XFE_E.SB.t9 XFE_E.NREGEN.t7 VSS.t43 nfet_03v3 ad=2.08p pd=8.52u as=2.08p ps=8.52u w=8u l=0.28u
X174 XFE_E.SXP.t10 XFE_E.XP.t48 VDD.t355 VDD.t354 pfet_03v3 ad=2.08p pd=8.52u as=2.08p ps=8.52u w=8u l=0.28u
X175 VDD.t110 XFE_E.SXP.t21 XFE_E.BP.t3 VDD.t109 pfet_03v3 ad=2.08p pd=8.52u as=3.52p ps=16.88u w=8u l=0.28u
X176 VDD.t138 E_REGEN_CLK.t31 XFE_E.XN.t10 VDD.t137 pfet_03v3 ad=2.08p pd=8.52u as=2.08p ps=8.52u w=8u l=0.28u
X177 a_n7157_n23500.t0 TERM_EN0_N.t1 a_n6400_n23452.t2 VDD.t92 pfet_03v3 ad=4.4p pd=20.88u as=2.6p ps=10.52u w=10u l=0.28u
X178 RXP.t5 a_n7300_n19900.t1 VSS.t98 ppolyf_u r_width=1u r_length=1u
X179 VSS.t12 E_SENSE_BOOST.t3 XFE_E.NTAIL.t2 VSS.t11 nfet_03v3 ad=2.08p pd=8.52u as=2.08p ps=8.52u w=8u l=0.28u
X180 XFE_E.SA.t3 E_SENSE_CLK.t2 VDD.t269 VDD.t165 pfet_03v3 ad=3.52p pd=16.88u as=2.08p ps=8.52u w=8u l=0.28u
X181 XFE_O.VREGN.t8 XFE_O.XP.t57 XFE_O.XN.t28 VDD.t360 pfet_03v3 ad=2.08p pd=8.52u as=3.52p ps=16.88u w=8u l=0.28u
X182 XFE_O.XP.t19 O_REGEN_CLK.t22 XFE_O.XN.t20 VDD.t237 pfet_03v3 ad=2.08p pd=8.52u as=2.08p ps=8.52u w=8u l=0.28u
X183 a_11748_41600.t0 SAMP_CLK_N.t1 a_10548_44200.t0 VSS.t270 nfet_03v3 ad=2.08p pd=8.52u as=3.52p ps=16.88u w=8u l=0.28u
X184 FE_O_P.t10 XFE_O.BP.t12 VSS.t144 VSS.t143 nfet_03v3 ad=2.08p pd=8.52u as=2.08p ps=8.52u w=8u l=0.28u
X185 VDD.t104 RX_RAWN.t0 VSS.t80 ppolyf_u r_width=2u r_length=3.43u
X186 VSS.t261 REST_BIAS.t3 a_n852_19400.t2 VSS.t260 nfet_03v3 ad=3.12p pd=12.52u as=5.28p ps=24.88u w=12u l=0.28u
X187 a_n7300_n14500.t4 a_n10800_n14372.t3 a_n6400_n14452.t4 VSS.t286 nfet_03v3 ad=4.4p pd=20.88u as=2.6p ps=10.52u w=10u l=0.28u
X188 VSS.t31 XFE_E.BP.t15 FE_E_N.t1 VSS.t30 nfet_03v3 ad=2.08p pd=8.52u as=3.52p ps=16.88u w=8u l=0.28u
X189 a_n10800_n12572.t1 TERM_EN6_N.t2 VSS.t1 VSS.t0 nfet_03v3 ad=0.44p pd=2.88u as=0.44p ps=2.88u w=1u l=0.28u
X190 XFE_O.XN.t10 O_REGEN_CLK.t16 VDD.t246 VDD.t209 pfet_03v3 ad=2.08p pd=8.52u as=2.08p ps=8.52u w=8u l=0.28u
X191 VDD.t219 O_REGEN_CLK.t11 XFE_O.NREGEN.t16 VDD.t218 pfet_03v3 ad=2.08p pd=8.52u as=3.52p ps=16.88u w=8u l=0.28u
X192 XFE_E.NREGEN.t8 XFE_E.SB.t12 XFE_E.XP.t4 VSS.t44 nfet_03v3 ad=2.08p pd=8.52u as=2.08p ps=8.52u w=8u l=0.28u
X193 XFE_E.BN.t7 XFE_E.SXN.t14 VSS.t185 VSS.t184 nfet_03v3 ad=2.08p pd=8.52u as=2.08p ps=8.52u w=8u l=0.28u
X194 VSS.t175 RX_BIAS.t0 a_2148_n500.t4 VSS.t169 nfet_03v3 ad=4.4p pd=20.88u as=2.6p ps=10.52u w=10u l=0.28u
X195 a_n10800_n21572.t0 TERM_EN1_N.t3 VDD.t315 VDD.t314 pfet_03v3 ad=0.88p pd=4.88u as=0.88p ps=4.88u w=2u l=0.28u
X196 XFE_O.SXN.t4 XFE_O.XN.t46 VDD.t188 VDD.t187 pfet_03v3 ad=2.08p pd=8.52u as=2.08p ps=8.52u w=8u l=0.28u
X197 VDD.t45 E_REGEN_CLKB.t11 XFE_E.VREGN.t4 VDD.t44 pfet_03v3 ad=2.08p pd=8.52u as=2.08p ps=8.52u w=8u l=0.28u
X198 XFE_E.VREGP.t10 XFE_E.XN.t55 XFE_E.XP.t5 VDD.t82 pfet_03v3 ad=2.08p pd=8.52u as=2.08p ps=8.52u w=8u l=0.28u
X199 VSS.t163 RX_BIAS.t11 a_n5052_2600.t6 VSS.t162 nfet_03v3 ad=0.52p pd=2.52u as=0.52p ps=2.52u w=2u l=0.28u
X200 a_n5052_n1000.t8 RXP.t9 a_n6572_3500.t3 VSS.t334 nfet_03v3 ad=2.6p pd=10.52u as=4.4p ps=20.88u w=10u l=0.28u
X201 VSS.t264 REST_BIAS.t7 a_n852_28800.t0 VSS.t260 nfet_03v3 ad=3.12p pd=12.52u as=5.28p ps=24.88u w=12u l=0.28u
X202 XFE_E.BP.t7 XFE_E.SXP.t18 VSS.t114 VSS.t113 nfet_03v3 ad=2.08p pd=8.52u as=2.08p ps=8.52u w=8u l=0.28u
X203 FE_E_N.t5 XFE_E.BP.t12 VSS.t77 VSS.t76 nfet_03v3 ad=2.08p pd=8.52u as=2.08p ps=8.52u w=8u l=0.28u
X204 VDD.t23 O_REGEN_CLKB.t7 XFE_O.VREGN.t0 VDD.t22 pfet_03v3 ad=2.08p pd=8.52u as=3.52p ps=16.88u w=8u l=0.28u
X205 XFE_E.NREGEN.t21 E_REGEN_CLK.t4 VSS.t131 VSS.t11 nfet_03v3 ad=2.08p pd=8.52u as=2.08p ps=8.52u w=8u l=0.28u
X206 VDD.t251 O_REGEN_CLK.t13 XFE_O.XN.t13 VDD.t250 pfet_03v3 ad=2.08p pd=8.52u as=2.08p ps=8.52u w=8u l=0.28u
X207 FE_O_N.t4 XFE_O.BN.t20 VDD.t343 VDD.t342 pfet_03v3 ad=2.08p pd=8.52u as=2.08p ps=8.52u w=8u l=0.28u
X208 XFE_O.XN.t0 XFE_O.SA.t11 XFE_O.NREGEN.t1 VSS.t39 nfet_03v3 ad=2.08p pd=8.52u as=2.08p ps=8.52u w=8u l=0.28u
X209 a_n7300_n18100.t2 a_n10800_n17972.t3 a_n6400_n18052.t3 VSS.t246 nfet_03v3 ad=4.4p pd=20.88u as=2.6p ps=10.52u w=10u l=0.28u
X210 VDD.t158 E_REGEN_CLK.t17 XFE_E.XP.t20 VDD.t157 pfet_03v3 ad=2.08p pd=8.52u as=2.08p ps=8.52u w=8u l=0.28u
X211 VSS.t313 SAMP_BIAS.t7 a_2148_41600.t4 VSS.t312 nfet_03v3 ad=2.6p pd=10.52u as=4.4p ps=20.88u w=10u l=0.28u
X212 VDD.t190 XFE_O.XN.t43 XFE_O.SXN.t5 VDD.t189 pfet_03v3 ad=2.08p pd=8.52u as=2.08p ps=8.52u w=8u l=0.28u
X213 XFE_E.VREGN.t1 E_REGEN_CLKB.t14 VDD.t41 VDD.t40 pfet_03v3 ad=2.08p pd=8.52u as=2.08p ps=8.52u w=8u l=0.28u
X214 a_n6400_n21652.t3 TERM_EN1_N.t0 a_n7157_n21700.t4 VDD.t317 pfet_03v3 ad=2.6p pd=10.52u as=4.4p ps=20.88u w=10u l=0.28u
X215 a_n6400_n21652.t2 RXN.t7 VSS.t249 ppolyf_u r_width=1u r_length=2.43u
X216 VDD.t368 XFE_O.BP.t23 FE_O_P.t13 VDD.t367 pfet_03v3 ad=2.08p pd=8.52u as=3.52p ps=16.88u w=8u l=0.28u
X217 VDD.t225 O_REGEN_CLK.t33 XFE_O.XP.t8 VDD.t224 pfet_03v3 ad=2.08p pd=8.52u as=2.08p ps=8.52u w=8u l=0.28u
X218 a_948_44200.t0 RX_RESTP.t6 SAMP_E_N.t3 VSS.t273 nfet_03v3 ad=1.56p pd=6.52u as=2.64p ps=12.88u w=6u l=0.28u
X219 XFE_E.SB.t3 E_SENSE_CLK.t6 VDD.t271 VDD.t137 pfet_03v3 ad=3.52p pd=16.88u as=2.08p ps=8.52u w=8u l=0.28u
X220 XFE_O.XP.t29 XFE_O.XN.t52 XFE_O.VREGP.t13 VDD.t97 pfet_03v3 ad=2.08p pd=8.52u as=2.08p ps=8.52u w=8u l=0.28u
X221 a_n6400_n12652.t4 a_n10800_n12572.t2 a_n7300_n12700.t4 VSS.t248 nfet_03v3 ad=2.6p pd=10.52u as=4.4p ps=20.88u w=10u l=0.28u
X222 a_948_44200.t2 RX_RESTN.t6 SAMP_E_P.t3 VSS.t288 nfet_03v3 ad=1.56p pd=6.52u as=2.64p ps=12.88u w=6u l=0.28u
X223 VDD.t349 XFE_O.BN.t17 FE_O_N.t9 VDD.t348 pfet_03v3 ad=2.08p pd=8.52u as=2.08p ps=8.52u w=8u l=0.28u
X224 XFE_E.NTAIL.t5 E_SENSE_BOOST.t0 VSS.t4 VSS.t3 nfet_03v3 ad=3.52p pd=16.88u as=2.08p ps=8.52u w=8u l=0.28u
X225 VDD.t370 XFE_O.XP.t49 XFE_O.SXP.t0 VDD.t369 pfet_03v3 ad=2.08p pd=8.52u as=3.52p ps=16.88u w=8u l=0.28u
X226 VDD.t17 O_REGEN_CLKB.t9 XFE_O.VREGP.t6 VDD.t16 pfet_03v3 ad=2.08p pd=8.52u as=2.08p ps=8.52u w=8u l=0.28u
X227 XFE_O.XN.t17 O_REGEN_CLK.t25 XFE_O.XP.t16 VDD.t236 pfet_03v3 ad=2.08p pd=8.52u as=2.08p ps=8.52u w=8u l=0.28u
X228 a_2148_41600.t7 SAMP_BIAS.t4 VSS.t321 VSS.t320 nfet_03v3 ad=4.4p pd=20.88u as=2.6p ps=10.52u w=10u l=0.28u
X229 XFE_E.BP.t0 XFE_E.SXP.t12 VSS.t50 VSS.t49 nfet_03v3 ad=3.52p pd=16.88u as=2.08p ps=8.52u w=8u l=0.28u
X230 a_12148_44200.t0 SAMP_O_P.t6 SAMP_O_N.t4 VSS.t36 nfet_03v3 ad=1.56p pd=6.52u as=2.64p ps=12.88u w=6u l=0.28u
X231 FE_E_N.t13 XFE_E.BP.t10 VSS.t364 VSS.t363 nfet_03v3 ad=3.52p pd=16.88u as=2.08p ps=8.52u w=8u l=0.28u
X232 VDD.t210 O_SENSE_CLK.t3 XFE_O.SB.t2 VDD.t209 pfet_03v3 ad=2.08p pd=8.52u as=3.52p ps=16.88u w=8u l=0.28u
X233 FE_O_N.t12 XFE_O.BN.t12 VSS.t346 VSS.t345 nfet_03v3 ad=2.08p pd=8.52u as=2.08p ps=8.52u w=8u l=0.28u
X234 XFE_O.NREGEN.t27 O_REGEN_CLK.t0 VSS.t207 VSS.t206 nfet_03v3 ad=3.52p pd=16.88u as=2.08p ps=8.52u w=8u l=0.28u
X235 XFE_O.XP.t11 O_REGEN_CLK.t30 VDD.t231 VDD.t230 pfet_03v3 ad=2.08p pd=8.52u as=2.08p ps=8.52u w=8u l=0.28u
X236 VSS.t250 O_SENSE_BOOST.t5 XFE_O.NTAIL.t6 VSS.t196 nfet_03v3 ad=2.08p pd=8.52u as=3.52p ps=16.88u w=8u l=0.28u
X237 XFE_E.NREGEN.t4 XFE_E.SA.t8 XFE_E.XN.t1 VSS.t40 nfet_03v3 ad=2.08p pd=8.52u as=2.08p ps=8.52u w=8u l=0.28u
X238 XFE_O.SXN.t1 XFE_O.XN.t40 VSS.t48 VSS.t47 nfet_03v3 ad=2.08p pd=8.52u as=2.08p ps=8.52u w=8u l=0.28u
X239 a_n10800_n16172.t1 TERM_EN4_N.t2 VSS.t287 VSS.t0 nfet_03v3 ad=0.44p pd=2.88u as=0.44p ps=2.88u w=1u l=0.28u
X240 XFE_E.XP.t6 XFE_E.XN.t52 XFE_E.VREGP.t13 VDD.t85 pfet_03v3 ad=2.08p pd=8.52u as=2.08p ps=8.52u w=8u l=0.28u
X241 SAMP_E_P.t0 SAMP_E_N.t5 a_2548_44200.t3 VSS.t211 nfet_03v3 ad=2.64p pd=12.88u as=1.56p ps=6.52u w=6u l=0.28u
X242 XFE_O.NTAIL.t3 SAMP_O_N.t8 XFE_O.SB.t0 VSS.t105 nfet_03v3 ad=2.08p pd=8.52u as=3.52p ps=16.88u w=8u l=0.28u
X243 VSS.t126 XFE_O.SXP.t19 XFE_O.BP.t2 VSS.t125 nfet_03v3 ad=2.08p pd=8.52u as=3.52p ps=16.88u w=8u l=0.28u
X244 XFE_E.SA.t1 SAMP_E_N.t7 XFE_E.NTAIL.t8 VSS.t209 nfet_03v3 ad=3.52p pd=16.88u as=2.08p ps=8.52u w=8u l=0.28u
X245 VSS.t93 XFE_E.SXP.t15 XFE_E.BP.t4 VSS.t92 nfet_03v3 ad=2.08p pd=8.52u as=2.08p ps=8.52u w=8u l=0.28u
X246 VDD.t134 E_REGEN_CLK.t33 XFE_E.XN.t8 VDD.t133 pfet_03v3 ad=2.08p pd=8.52u as=2.08p ps=8.52u w=8u l=0.28u
X247 VSS.t134 E_REGEN_CLK.t1 XFE_E.NREGEN.t24 VSS.t3 nfet_03v3 ad=2.08p pd=8.52u as=2.08p ps=8.52u w=8u l=0.28u
X248 SAMP_O_P.t4 RX_RESTN.t3 a_10548_44200.t5 VSS.t291 nfet_03v3 ad=2.64p pd=12.88u as=1.56p ps=6.52u w=6u l=0.28u
X249 XFE_E.SA.t6 VSS.t371 VDD.t288 VDD.t287 pfet_03v3 ad=3.52p pd=16.88u as=3.52p ps=16.88u w=8u l=0.28u
X250 XFE_O.VREGN.t10 XFE_O.XP.t55 XFE_O.XN.t24 VDD.t334 pfet_03v3 ad=2.08p pd=8.52u as=2.08p ps=8.52u w=8u l=0.28u
X251 FE_E_P.t10 XFE_E.BN.t20 VDD.t274 VDD.t273 pfet_03v3 ad=2.08p pd=8.52u as=2.08p ps=8.52u w=8u l=0.28u
X252 XFE_O.NTAIL.t9 O_SENSE_BOOST.t2 VSS.t253 VSS.t192 nfet_03v3 ad=2.08p pd=8.52u as=2.08p ps=8.52u w=8u l=0.28u
X253 VSS.t111 XFE_O.SXN.t19 XFE_O.BN.t0 VSS.t110 nfet_03v3 ad=2.08p pd=8.52u as=3.52p ps=16.88u w=8u l=0.28u
X254 XFE_E.XN.t22 XFE_E.SA.t11 XFE_E.NREGEN.t26 VSS.t228 nfet_03v3 ad=2.08p pd=8.52u as=2.08p ps=8.52u w=8u l=0.28u
X255 XFE_E.XP.t23 E_REGEN_CLK.t14 VDD.t168 VDD.t167 pfet_03v3 ad=2.08p pd=8.52u as=2.08p ps=8.52u w=8u l=0.28u
X256 a_2148_n500.t7 a_n3600_5641.t7 RX_RAWN.t2 VSS.t88 nfet_03v3 ad=1.3p pd=5.52u as=2.2p ps=10.88u w=5u l=0.28u
X257 a_n10800_n19772.t1 TERM_EN2_N.t2 VSS.t302 VSS.t0 nfet_03v3 ad=0.44p pd=2.88u as=0.44p ps=2.88u w=1u l=0.28u
X258 XFE_O.NREGEN.t21 O_REGEN_CLK.t6 VSS.t197 VSS.t196 nfet_03v3 ad=2.08p pd=8.52u as=2.08p ps=8.52u w=8u l=0.28u
X259 a_2148_41600.t0 SAMP_CLK_N.t3 a_2548_44200.t4 VSS.t268 nfet_03v3 ad=2.08p pd=8.52u as=3.52p ps=16.88u w=8u l=0.28u
X260 XFE_O.VREGP.t10 XFE_O.XN.t55 XFE_O.XP.t28 VDD.t68 pfet_03v3 ad=2.08p pd=8.52u as=2.08p ps=8.52u w=8u l=0.28u
X261 XFE_O.XN.t27 XFE_O.XP.t52 XFE_O.VREGN.t13 VDD.t337 pfet_03v3 ad=2.08p pd=8.52u as=2.08p ps=8.52u w=8u l=0.28u
X262 XFE_E.XN.t20 E_REGEN_CLK.t21 XFE_E.XP.t27 VDD.t151 pfet_03v3 ad=2.08p pd=8.52u as=2.08p ps=8.52u w=8u l=0.28u
X263 a_n6400_n16252.t1 a_n10800_n16172.t2 a_n7300_n16300.t1 VSS.t240 nfet_03v3 ad=2.6p pd=10.52u as=4.4p ps=20.88u w=10u l=0.28u
X264 XFE_O.VREGP.t3 O_REGEN_CLKB.t12 VDD.t11 VDD.t10 pfet_03v3 ad=2.08p pd=8.52u as=2.08p ps=8.52u w=8u l=0.28u
X265 XFE_E.XP.t7 XFE_E.XN.t37 XFE_E.NREGEN.t10 VSS.t62 nfet_03v3 ad=2.08p pd=8.52u as=3.52p ps=16.88u w=8u l=0.28u
X266 VDD.t257 O_REGEN_CLK.t9 XFE_O.NREGEN.t18 VDD.t256 pfet_03v3 ad=2.08p pd=8.52u as=3.52p ps=16.88u w=8u l=0.28u
X267 XFE_E.NREGEN.t32 XFE_E.XP.t36 XFE_E.XN.t31 VSS.t350 nfet_03v3 ad=2.08p pd=8.52u as=2.08p ps=8.52u w=8u l=0.28u
X268 VSS.t124 XFE_E.SXN.t19 XFE_E.BN.t2 VSS.t123 nfet_03v3 ad=2.08p pd=8.52u as=3.52p ps=16.88u w=8u l=0.28u
X269 VSS.t340 XFE_O.BN.t15 FE_O_N.t7 VSS.t339 nfet_03v3 ad=2.08p pd=8.52u as=3.52p ps=16.88u w=8u l=0.28u
X270 VSS.t193 O_REGEN_CLK.t3 XFE_O.NREGEN.t24 VSS.t192 nfet_03v3 ad=2.08p pd=8.52u as=2.08p ps=8.52u w=8u l=0.28u
X271 RXP.t0 a_n7157_n21700.t0 VSS.t98 ppolyf_u r_width=1u r_length=2.43u
X272 VDD.t394 XFE_E.XN.t43 XFE_E.SXN.t11 VDD.t393 pfet_03v3 ad=2.08p pd=8.52u as=2.08p ps=8.52u w=8u l=0.28u
X273 XFE_E.XP.t28 E_REGEN_CLK.t24 XFE_E.XN.t17 VDD.t148 pfet_03v3 ad=2.08p pd=8.52u as=2.08p ps=8.52u w=8u l=0.28u
X274 RXP.t4 RXN.t6 VSS.t178 ppolyf_u r_width=4u r_length=1.23u
X275 SAMP_O_N.t1 RX_RESTP.t3 a_10548_44200.t3 VSS.t276 nfet_03v3 ad=2.64p pd=12.88u as=1.56p ps=6.52u w=6u l=0.28u
X276 XFE_O.NREGEN.t28 XFE_O.SB.t14 XFE_O.XP.t22 VSS.t245 nfet_03v3 ad=2.08p pd=8.52u as=3.52p ps=16.88u w=8u l=0.28u
X277 VDD.t353 XFE_E.XP.t47 XFE_E.SXP.t9 VDD.t352 pfet_03v3 ad=2.08p pd=8.52u as=2.08p ps=8.52u w=8u l=0.28u
X278 XFE_E.BP.t9 XFE_E.SXP.t20 VDD.t120 VDD.t119 pfet_03v3 ad=3.52p pd=16.88u as=2.08p ps=8.52u w=8u l=0.28u
X279 XFE_E.XN.t11 E_REGEN_CLK.t30 VDD.t140 VDD.t139 pfet_03v3 ad=2.08p pd=8.52u as=2.08p ps=8.52u w=8u l=0.28u
X280 a_n6400_n19852.t1 a_n10800_n19772.t2 a_n7300_n19900.t0 VSS.t244 nfet_03v3 ad=2.6p pd=10.52u as=4.4p ps=20.88u w=10u l=0.28u
X281 XFE_E.NTAIL.t3 E_SENSE_BOOST.t2 VSS.t10 VSS.t9 nfet_03v3 ad=2.08p pd=8.52u as=2.08p ps=8.52u w=8u l=0.28u
X282 XFE_O.NREGEN.t10 XFE_O.XN.t35 XFE_O.XP.t33 VSS.t152 nfet_03v3 ad=3.52p pd=16.88u as=2.08p ps=8.52u w=8u l=0.28u
X283 VDD.t373 XFE_O.XP.t47 XFE_O.SXP.t1 VDD.t372 pfet_03v3 ad=2.08p pd=8.52u as=2.08p ps=8.52u w=8u l=0.28u
X284 VDD.t323 XFE_E.BN.t17 FE_E_P.t13 VDD.t322 pfet_03v3 ad=2.08p pd=8.52u as=2.08p ps=8.52u w=8u l=0.28u
X285 VSS.t100 XFE_O.BP.t13 FE_O_P.t2 VSS.t99 nfet_03v3 ad=2.08p pd=8.52u as=2.08p ps=8.52u w=8u l=0.28u
X286 VDD.t65 E_REGEN_CLKB.t1 XFE_E.VREGP.t6 VDD.t64 pfet_03v3 ad=2.08p pd=8.52u as=2.08p ps=8.52u w=8u l=0.28u
X287 FE_O_P.t7 XFE_O.BP.t18 VDD.t183 VDD.t182 pfet_03v3 ad=2.08p pd=8.52u as=2.08p ps=8.52u w=8u l=0.28u
X288 XFE_E.SXN.t5 XFE_E.XN.t46 VDD.t101 VDD.t100 pfet_03v3 ad=2.08p pd=8.52u as=2.08p ps=8.52u w=8u l=0.28u
X289 a_n7157_n23500.t2 a_n10800_n23372.t3 a_n6400_n23452.t3 VSS.t239 nfet_03v3 ad=4.4p pd=20.88u as=2.6p ps=10.52u w=10u l=0.28u
X290 a_n10800_n21572.t1 TERM_EN1_N.t2 VSS.t305 VSS.t0 nfet_03v3 ad=0.44p pd=2.88u as=0.44p ps=2.88u w=1u l=0.28u
X291 VSS.t171 RX_BIAS.t5 a_n5052_n1000.t6 VSS.t169 nfet_03v3 ad=4.4p pd=20.88u as=2.6p ps=10.52u w=10u l=0.28u
X292 a_n7300_n12700.t0 TERM_EN6_N.t1 a_n6400_n12652.t1 VDD.t2 pfet_03v3 ad=4.4p pd=20.88u as=2.6p ps=10.52u w=10u l=0.28u
X293 XFE_E.XN.t25 XFE_E.XP.t54 XFE_E.VREGN.t11 VDD.t302 pfet_03v3 ad=2.08p pd=8.52u as=2.08p ps=8.52u w=8u l=0.28u
X294 a_n5052_n1000.t1 RXN.t9 a_n3600_5641.t0 VSS.t88 nfet_03v3 ad=2.6p pd=10.52u as=4.4p ps=20.88u w=10u l=0.28u
X295 VDD.t95 a_n1000_22678.t0 VSS.t68 ppolyf_u r_width=2u r_length=4.2u
X296 VSS.t6 E_SENSE_BOOST.t5 XFE_E.NTAIL.t0 VSS.t5 nfet_03v3 ad=2.08p pd=8.52u as=3.52p ps=16.88u w=8u l=0.28u
X297 XFE_O.SXP.t9 XFE_O.XP.t44 VDD.t383 VDD.t382 pfet_03v3 ad=2.08p pd=8.52u as=2.08p ps=8.52u w=8u l=0.28u
X298 XFE_O.XP.t21 O_REGEN_CLK.t20 XFE_O.XN.t22 VDD.t239 pfet_03v3 ad=3.52p pd=16.88u as=2.08p ps=8.52u w=8u l=0.28u
X299 FE_O_P.t8 XFE_O.BP.t10 VSS.t140 VSS.t139 nfet_03v3 ad=3.52p pd=16.88u as=2.08p ps=8.52u w=8u l=0.28u
X300 FE_E_N.t8 XFE_E.BP.t20 VDD.t217 VDD.t216 pfet_03v3 ad=2.08p pd=8.52u as=2.08p ps=8.52u w=8u l=0.28u
X301 VSS.t79 XFE_E.BP.t13 FE_E_N.t6 VSS.t78 nfet_03v3 ad=2.08p pd=8.52u as=2.08p ps=8.52u w=8u l=0.28u
X302 XFE_E.VREGP.t3 E_REGEN_CLKB.t4 VDD.t61 VDD.t60 pfet_03v3 ad=2.08p pd=8.52u as=2.08p ps=8.52u w=8u l=0.28u
X303 VSS.t132 E_REGEN_CLK.t3 XFE_E.NREGEN.t22 VSS.t9 nfet_03v3 ad=2.08p pd=8.52u as=2.08p ps=8.52u w=8u l=0.28u
X304 XFE_E.NREGEN.t28 XFE_E.SB.t14 XFE_E.XP.t31 VSS.t282 nfet_03v3 ad=2.08p pd=8.52u as=3.52p ps=16.88u w=8u l=0.28u
X305 VDD.t164 E_REGEN_CLK.t11 XFE_E.NREGEN.t14 VDD.t163 pfet_03v3 ad=2.08p pd=8.52u as=3.52p ps=16.88u w=8u l=0.28u
X306 VDD.t286 VSS.t370 XFE_O.SA.t6 VDD.t285 pfet_03v3 ad=3.52p pd=16.88u as=3.52p ps=16.88u w=8u l=0.28u
X307 VDD.t43 E_REGEN_CLKB.t13 XFE_E.VREGN.t2 VDD.t42 pfet_03v3 ad=2.08p pd=8.52u as=2.08p ps=8.52u w=8u l=0.28u
X308 XFE_E.VREGP.t8 XFE_E.XN.t57 XFE_E.XP.t12 VDD.t99 pfet_03v3 ad=2.08p pd=8.52u as=3.52p ps=16.88u w=8u l=0.28u
X309 VDD.t94 RX_RESTP.t0 VSS.t68 ppolyf_u r_width=2u r_length=4.2u
X310 XFE_E.SB.t4 E_SENSE_CLK.t5 XFE_E.SA.t4 VDD.t148 pfet_03v3 ad=2.08p pd=8.52u as=3.52p ps=16.88u w=8u l=0.28u
X311 XFE_O.BP.t7 XFE_O.SXP.t14 VSS.t22 VSS.t21 nfet_03v3 ad=2.08p pd=8.52u as=2.08p ps=8.52u w=8u l=0.28u
X312 a_12148_44200.t5 SAMP_CLK_P.t0 a_11748_41600.t3 VSS.t309 nfet_03v3 ad=3.52p pd=16.88u as=2.08p ps=8.52u w=8u l=0.28u
X313 VSS.t301 XFE_E.XP.t41 XFE_E.SXP.t3 VSS.t300 nfet_03v3 ad=2.08p pd=8.52u as=3.52p ps=16.88u w=8u l=0.28u
X314 a_n6400_n14452.t2 RXN.t3 VSS.t112 ppolyf_u r_width=1u r_length=1u
X315 VDD.t27 O_REGEN_CLKB.t5 XFE_O.VREGN.t2 VDD.t26 pfet_03v3 ad=2.08p pd=8.52u as=2.08p ps=8.52u w=8u l=0.28u
X316 XFE_O.VREGP.t12 XFE_O.XN.t53 XFE_O.XP.t24 VDD.t267 pfet_03v3 ad=2.08p pd=8.52u as=2.08p ps=8.52u w=8u l=0.28u
X317 XFE_E.NREGEN.t19 E_REGEN_CLK.t6 VSS.t129 VSS.t5 nfet_03v3 ad=2.08p pd=8.52u as=2.08p ps=8.52u w=8u l=0.28u
X318 a_n6400_n21652.t0 a_n10800_n21572.t2 a_n7157_n21700.t1 VSS.t218 nfet_03v3 ad=2.6p pd=10.52u as=4.4p ps=20.88u w=10u l=0.28u
X319 VSS.t359 XFE_O.XP.t41 XFE_O.SXP.t10 VSS.t358 nfet_03v3 ad=2.08p pd=8.52u as=3.52p ps=16.88u w=8u l=0.28u
X320 VDD.t154 E_REGEN_CLK.t19 XFE_E.XP.t18 VDD.t153 pfet_03v3 ad=2.08p pd=8.52u as=3.52p ps=16.88u w=8u l=0.28u
X321 VDD.t313 a_n6572_3500.t2 VSS.t304 ppolyf_u r_width=2u r_length=4.57u
X322 XFE_O.XP.t15 O_REGEN_CLK.t26 XFE_O.XN.t16 VDD.t235 pfet_03v3 ad=2.08p pd=8.52u as=2.08p ps=8.52u w=8u l=0.28u
X323 VSS.t317 SAMP_BIAS.t5 a_2148_41600.t6 VSS.t316 nfet_03v3 ad=2.6p pd=10.52u as=2.6p ps=10.52u w=10u l=0.28u
X324 XFE_E.SXN.t4 XFE_E.XN.t40 VSS.t66 VSS.t65 nfet_03v3 ad=2.08p pd=8.52u as=2.08p ps=8.52u w=8u l=0.28u
X325 VDD.t73 XFE_O.BP.t21 FE_O_P.t0 VDD.t72 pfet_03v3 ad=2.08p pd=8.52u as=2.08p ps=8.52u w=8u l=0.28u
X326 VDD.t295 a_5300_5958.t0 VSS.t283 ppolyf_u r_width=1u r_length=1.4u
X327 VSS.t266 REST_BIAS.t1 a_n852_19400.t4 VSS.t256 nfet_03v3 ad=3.12p pd=12.52u as=3.12p ps=12.52u w=12u l=0.28u
X328 VDD.t281 SAMP_E_N.t2 VSS.t241 ppolyf_u r_width=2u r_length=5u
X329 XFE_O.XN.t34 XFE_O.XP.t36 XFE_O.NREGEN.t33 VSS.t361 nfet_03v3 ad=2.08p pd=8.52u as=2.08p ps=8.52u w=8u l=0.28u
X330 VDD.t227 O_REGEN_CLK.t31 XFE_O.XP.t10 VDD.t205 pfet_03v3 ad=2.08p pd=8.52u as=2.08p ps=8.52u w=8u l=0.28u
X331 XFE_O.VREGN.t5 O_REGEN_CLKB.t2 VDD.t31 VDD.t30 pfet_03v3 ad=2.08p pd=8.52u as=2.08p ps=8.52u w=8u l=0.28u
X332 XFE_O.XP.t25 XFE_O.XN.t50 XFE_O.VREGP.t15 VDD.t388 pfet_03v3 ad=3.52p pd=16.88u as=2.08p ps=8.52u w=8u l=0.28u
X333 XFE_E.VREGN.t14 XFE_E.XP.t51 XFE_E.XN.t34 VDD.t366 pfet_03v3 ad=2.08p pd=8.52u as=2.08p ps=8.52u w=8u l=0.28u
X334 a_n852_28800.t5 a_n1000_22678.t4 RX_RESTP.t1 VSS.t117 nfet_03v3 ad=2.6p pd=10.52u as=4.4p ps=20.88u w=10u l=0.28u
X335 a_2548_44200.t2 SAMP_E_N.t6 SAMP_E_P.t1 VSS.t210 nfet_03v3 ad=1.56p pd=6.52u as=2.64p ps=12.88u w=6u l=0.28u
X336 XFE_O.SXP.t7 XFE_O.XP.t38 VSS.t357 VSS.t356 nfet_03v3 ad=3.52p pd=16.88u as=2.08p ps=8.52u w=8u l=0.28u
X337 XFE_O.XN.t19 O_REGEN_CLK.t23 XFE_O.XP.t18 VDD.t208 pfet_03v3 ad=2.08p pd=8.52u as=2.08p ps=8.52u w=8u l=0.28u
X338 a_n7300_n16300.t2 TERM_EN4_N.t1 a_n6400_n16252.t2 VDD.t298 pfet_03v3 ad=4.4p pd=20.88u as=2.6p ps=10.52u w=10u l=0.28u
X339 XFE_E.BP.t2 XFE_E.SXP.t14 VSS.t54 VSS.t53 nfet_03v3 ad=2.08p pd=8.52u as=2.08p ps=8.52u w=8u l=0.28u
X340 VSS.t257 REST_BIAS.t5 a_n852_28800.t2 VSS.t256 nfet_03v3 ad=3.12p pd=12.52u as=3.12p ps=12.52u w=12u l=0.28u
X341 FE_O_N.t10 XFE_O.BN.t10 VSS.t342 VSS.t341 nfet_03v3 ad=3.52p pd=16.88u as=2.08p ps=8.52u w=8u l=0.28u
X342 XFE_E.NREGEN.t25 E_REGEN_CLK.t0 VSS.t136 VSS.t135 nfet_03v3 ad=3.52p pd=16.88u as=2.08p ps=8.52u w=8u l=0.28u
X343 a_10548_44200.t4 RX_RESTN.t4 SAMP_O_P.t3 VSS.t290 nfet_03v3 ad=1.56p pd=6.52u as=2.64p ps=12.88u w=6u l=0.28u
X344 XFE_O.XP.t13 O_REGEN_CLK.t28 VDD.t229 VDD.t228 pfet_03v3 ad=3.52p pd=16.88u as=2.08p ps=8.52u w=8u l=0.28u
X345 a_n852_19400.t0 RX_RAWP.t5 a_n1000_22678.t1 VSS.t117 nfet_03v3 ad=2.6p pd=10.52u as=4.4p ps=20.88u w=10u l=0.28u
X346 VSS.t252 O_SENSE_BOOST.t3 XFE_O.NTAIL.t8 VSS.t200 nfet_03v3 ad=2.08p pd=8.52u as=2.08p ps=8.52u w=8u l=0.28u
X347 XFE_E.NREGEN.t6 XFE_E.SA.t10 XFE_E.XN.t3 VSS.t42 nfet_03v3 ad=2.08p pd=8.52u as=2.08p ps=8.52u w=8u l=0.28u
X348 VDD.t103 XFE_E.BP.t23 FE_E_N.t3 VDD.t102 pfet_03v3 ad=2.08p pd=8.52u as=3.52p ps=16.88u w=8u l=0.28u
X349 a_948_44200.t5 SAMP_CLK_P.t2 a_2148_41600.t3 VSS.t307 nfet_03v3 ad=3.52p pd=16.88u as=2.08p ps=8.52u w=8u l=0.28u
X350 XFE_E.SXN.t7 XFE_E.XN.t48 VDD.t196 VDD.t195 pfet_03v3 ad=2.08p pd=8.52u as=2.08p ps=8.52u w=8u l=0.28u
X351 a_n10800_n14372.t0 TERM_EN5_N.t3 VDD.t112 VDD.t111 pfet_03v3 ad=0.88p pd=4.88u as=0.88p ps=4.88u w=2u l=0.28u
X352 XFE_O.NREGEN.t13 XFE_O.SA.t14 XFE_O.XN.t4 VSS.t157 nfet_03v3 ad=2.08p pd=8.52u as=3.52p ps=16.88u w=8u l=0.28u
X353 VSS.t59 XFE_O.SXP.t17 XFE_O.BP.t4 VSS.t58 nfet_03v3 ad=2.08p pd=8.52u as=2.08p ps=8.52u w=8u l=0.28u
X354 XFE_O.XP.t34 XFE_O.SB.t9 XFE_O.NREGEN.t29 VSS.t281 nfet_03v3 ad=2.08p pd=8.52u as=2.08p ps=8.52u w=8u l=0.28u
X355 VSS.t168 RX_BIAS.t7 a_n5052_n1000.t4 VSS.t165 nfet_03v3 ad=2.6p pd=10.52u as=2.6p ps=10.52u w=10u l=0.28u
X356 VSS.t97 XFE_E.SXP.t17 XFE_E.BP.t6 VSS.t96 nfet_03v3 ad=2.08p pd=8.52u as=2.08p ps=8.52u w=8u l=0.28u
X357 VDD.t130 E_REGEN_CLK.t35 XFE_E.XN.t6 VDD.t129 pfet_03v3 ad=2.08p pd=8.52u as=3.52p ps=16.88u w=8u l=0.28u
X358 XFE_O.XP.t27 XFE_O.XN.t56 XFE_O.VREGP.t9 VDD.t69 pfet_03v3 ad=2.08p pd=8.52u as=2.08p ps=8.52u w=8u l=0.28u
X359 a_n7300_n19900.t2 TERM_EN2_N.t1 a_n6400_n19852.t2 VDD.t310 pfet_03v3 ad=4.4p pd=20.88u as=2.6p ps=10.52u w=10u l=0.28u
X360 XFE_O.VREGN.t12 XFE_O.XP.t53 XFE_O.XN.t29 VDD.t361 pfet_03v3 ad=2.08p pd=8.52u as=2.08p ps=8.52u w=8u l=0.28u
X361 FE_E_P.t0 XFE_E.BN.t22 VDD.t106 VDD.t105 pfet_03v3 ad=2.08p pd=8.52u as=2.08p ps=8.52u w=8u l=0.28u
X362 a_n6400_n18052.t2 RXN.t1 VSS.t38 ppolyf_u r_width=1u r_length=1u
X363 XFE_O.NTAIL.t11 O_SENSE_BOOST.t0 VSS.t255 VSS.t204 nfet_03v3 ad=3.52p pd=16.88u as=2.08p ps=8.52u w=8u l=0.28u
X364 XFE_E.XN.t2 XFE_E.SA.t13 XFE_E.NREGEN.t5 VSS.t41 nfet_03v3 ad=2.08p pd=8.52u as=2.08p ps=8.52u w=8u l=0.28u
X365 VSS.t331 XFE_O.SXN.t17 XFE_O.BN.t7 VSS.t330 nfet_03v3 ad=2.08p pd=8.52u as=2.08p ps=8.52u w=8u l=0.28u
X366 XFE_E.VREGP.t1 E_REGEN_CLKB.t6 VDD.t55 VDD.t54 pfet_03v3 ad=2.08p pd=8.52u as=2.08p ps=8.52u w=8u l=0.28u
X367 XFE_E.XN.t32 XFE_E.XP.t35 XFE_E.NREGEN.t31 VSS.t349 nfet_03v3 ad=3.52p pd=16.88u as=2.08p ps=8.52u w=8u l=0.28u
X368 XFE_O.SA.t3 O_SENSE_CLK.t6 VDD.t206 VDD.t205 pfet_03v3 ad=3.52p pd=16.88u as=2.08p ps=8.52u w=8u l=0.28u
X369 VDD.t390 XFE_E.BP.t21 FE_E_N.t11 VDD.t389 pfet_03v3 ad=2.08p pd=8.52u as=2.08p ps=8.52u w=8u l=0.28u
X370 XFE_O.NREGEN.t23 O_REGEN_CLK.t4 VSS.t201 VSS.t200 nfet_03v3 ad=2.08p pd=8.52u as=2.08p ps=8.52u w=8u l=0.28u
X371 XFE_O.XP.t7 O_REGEN_CLK.t34 VDD.t223 VDD.t222 pfet_03v3 ad=2.08p pd=8.52u as=2.08p ps=8.52u w=8u l=0.28u
X372 a_n6400_n14452.t1 TERM_EN5_N.t0 a_n7300_n14500.t2 VDD.t114 pfet_03v3 ad=2.6p pd=10.52u as=4.4p ps=20.88u w=10u l=0.28u
X373 RX_RAWP.t1 a_n6572_3500.t6 a_2148_n500.t6 VSS.t88 nfet_03v3 ad=2.2p pd=10.88u as=1.3p ps=5.52u w=5u l=0.28u
X374 XFE_E.SXN.t8 XFE_E.XN.t42 VDD.t198 VDD.t197 pfet_03v3 ad=3.52p pd=16.88u as=2.08p ps=8.52u w=8u l=0.28u
X375 VDD.t291 a_600_22678.t0 VSS.t242 ppolyf_u r_width=2u r_length=4.2u
X376 XFE_E.XN.t18 E_REGEN_CLK.t23 XFE_E.XP.t29 VDD.t149 pfet_03v3 ad=2.08p pd=8.52u as=2.08p ps=8.52u w=8u l=0.28u
X377 XFE_O.XN.t31 XFE_O.XP.t50 XFE_O.VREGN.t15 VDD.t371 pfet_03v3 ad=3.52p pd=16.88u as=2.08p ps=8.52u w=8u l=0.28u
X378 XFE_O.SA.t5 O_SENSE_CLK.t4 XFE_O.SB.t4 VDD.t208 pfet_03v3 ad=3.52p pd=16.88u as=2.08p ps=8.52u w=8u l=0.28u
X379 XFE_O.BN.t4 XFE_O.SXN.t14 VSS.t225 VSS.t224 nfet_03v3 ad=2.08p pd=8.52u as=2.08p ps=8.52u w=8u l=0.28u
X380 a_10548_44200.t2 RX_RESTP.t4 SAMP_O_N.t0 VSS.t275 nfet_03v3 ad=1.56p pd=6.52u as=2.64p ps=12.88u w=6u l=0.28u
X381 RXP.t1 a_n7300_n14500.t0 VSS.t98 ppolyf_u r_width=1u r_length=1u
X382 VSS.t348 XFE_O.BN.t13 FE_O_N.t13 VSS.t347 nfet_03v3 ad=2.08p pd=8.52u as=2.08p ps=8.52u w=8u l=0.28u
X383 VSS.t205 O_REGEN_CLK.t1 XFE_O.NREGEN.t26 VSS.t204 nfet_03v3 ad=2.08p pd=8.52u as=2.08p ps=8.52u w=8u l=0.28u
X384 VDD.t325 XFE_E.XP.t43 XFE_E.SXP.t5 VDD.t324 pfet_03v3 ad=2.08p pd=8.52u as=2.08p ps=8.52u w=8u l=0.28u
X385 XFE_O.XP.t32 XFE_O.XN.t36 XFE_O.NREGEN.t11 VSS.t153 nfet_03v3 ad=2.08p pd=8.52u as=2.08p ps=8.52u w=8u l=0.28u
X386 a_11748_41600.t7 SAMP_BIAS.t0 VSS.t315 VSS.t314 nfet_03v3 ad=4.4p pd=20.88u as=2.6p ps=10.52u w=10u l=0.28u
X387 XFE_E.XN.t4 XFE_E.SA.t7 XFE_E.NREGEN.t9 VSS.t55 nfet_03v3 ad=3.52p pd=16.88u as=2.08p ps=8.52u w=8u l=0.28u
X388 FE_E_P.t12 XFE_E.BN.t16 VDD.t321 VDD.t320 pfet_03v3 ad=3.52p pd=16.88u as=2.08p ps=8.52u w=8u l=0.28u
X389 XFE_E.VREGP.t7 E_REGEN_CLKB.t0 VDD.t67 VDD.t66 pfet_03v3 ad=3.52p pd=16.88u as=2.08p ps=8.52u w=8u l=0.28u
X390 VDD.t282 RX_RESTN.t0 VSS.t242 ppolyf_u r_width=2u r_length=4.2u
X391 SAMP_E_N.t1 SAMP_E_P.t5 a_2548_44200.t1 VSS.t72 nfet_03v3 ad=2.64p pd=12.88u as=1.56p ps=6.52u w=6u l=0.28u
X392 VDD.t357 XFE_O.BP.t19 FE_O_P.t11 VDD.t356 pfet_03v3 ad=2.08p pd=8.52u as=2.08p ps=8.52u w=8u l=0.28u
X393 VDD.t88 XFE_E.XN.t45 XFE_E.SXN.t3 VDD.t87 pfet_03v3 ad=2.08p pd=8.52u as=2.08p ps=8.52u w=8u l=0.28u
X394 a_n6572_3500.t1 VTHP.t0 a_n5052_2600.t1 VSS.t15 nfet_03v3 ad=0.88p pd=4.88u as=0.52p ps=2.52u w=2u l=0.28u
X395 XFE_E.XP.t16 E_REGEN_CLK.t26 XFE_E.XN.t15 VDD.t146 pfet_03v3 ad=2.08p pd=8.52u as=2.08p ps=8.52u w=8u l=0.28u
X396 VDD.t241 O_REGEN_CLK.t19 XFE_O.XN.t7 VDD.t240 pfet_03v3 ad=2.08p pd=8.52u as=3.52p ps=16.88u w=8u l=0.28u
X397 a_2148_n500.t1 RX_BIAS.t3 VSS.t172 VSS.t169 nfet_03v3 ad=2.6p pd=10.52u as=2.6p ps=10.52u w=10u l=0.28u
X398 XFE_O.NREGEN.t0 XFE_O.SB.t12 XFE_O.XP.t0 VSS.t2 nfet_03v3 ad=2.08p pd=8.52u as=2.08p ps=8.52u w=8u l=0.28u
X399 VDD.t364 XFE_E.XP.t49 XFE_E.SXP.t11 VDD.t363 pfet_03v3 ad=2.08p pd=8.52u as=3.52p ps=16.88u w=8u l=0.28u
X400 XFE_O.VREGN.t7 O_REGEN_CLKB.t0 VDD.t35 VDD.t34 pfet_03v3 ad=3.52p pd=16.88u as=2.08p ps=8.52u w=8u l=0.28u
X401 VDD.t387 XFE_O.XN.t49 XFE_O.SXN.t11 VDD.t386 pfet_03v3 ad=2.08p pd=8.52u as=3.52p ps=16.88u w=8u l=0.28u
X402 a_n10800_n17972.t0 TERM_EN3_N.t3 VDD.t79 VDD.t78 pfet_03v3 ad=0.88p pd=4.88u as=0.88p ps=4.88u w=2u l=0.28u
X403 SAMP_O_P.t0 SAMP_O_N.t5 a_12148_44200.t3 VSS.t108 nfet_03v3 ad=2.64p pd=12.88u as=1.56p ps=6.52u w=6u l=0.28u
X404 VDD.t292 a_n1900_5958.t0 VSS.t272 ppolyf_u r_width=1u r_length=1.4u
X405 a_n7157_n21700.t3 TERM_EN1_N.t1 a_n6400_n21652.t4 VDD.t316 pfet_03v3 ad=4.4p pd=20.88u as=2.6p ps=10.52u w=10u l=0.28u
X406 XFE_E.NTAIL.t1 E_SENSE_BOOST.t4 VSS.t8 VSS.t7 nfet_03v3 ad=2.08p pd=8.52u as=2.08p ps=8.52u w=8u l=0.28u
X407 VDD.t377 XFE_O.XP.t45 XFE_O.SXP.t3 VDD.t376 pfet_03v3 ad=2.08p pd=8.52u as=2.08p ps=8.52u w=8u l=0.28u
X408 XFE_O.XN.t21 O_REGEN_CLK.t21 XFE_O.XP.t20 VDD.t238 pfet_03v3 ad=2.08p pd=8.52u as=2.08p ps=8.52u w=8u l=0.28u
X409 XFE_O.XN.t25 XFE_O.XP.t56 XFE_O.VREGN.t9 VDD.t335 pfet_03v3 ad=2.08p pd=8.52u as=2.08p ps=8.52u w=8u l=0.28u
X410 VDD.t124 XFE_E.BN.t19 FE_E_P.t3 VDD.t123 pfet_03v3 ad=2.08p pd=8.52u as=2.08p ps=8.52u w=8u l=0.28u
X411 FE_E_N.t10 XFE_E.BP.t18 VDD.t266 VDD.t265 pfet_03v3 ad=2.08p pd=8.52u as=2.08p ps=8.52u w=8u l=0.28u
X412 VDD.t59 E_REGEN_CLKB.t3 XFE_E.VREGP.t4 VDD.t58 pfet_03v3 ad=2.08p pd=8.52u as=2.08p ps=8.52u w=8u l=0.28u
X413 FE_O_P.t5 XFE_O.BP.t16 VDD.t179 VDD.t178 pfet_03v3 ad=3.52p pd=16.88u as=2.08p ps=8.52u w=8u l=0.28u
X414 a_n7300_n12700.t3 a_n10800_n12572.t3 a_n6400_n12652.t3 VSS.t243 nfet_03v3 ad=4.4p pd=20.88u as=2.6p ps=10.52u w=10u l=0.28u
X415 VDD.t333 XFE_O.BN.t23 FE_O_N.t1 VDD.t332 pfet_03v3 ad=2.08p pd=8.52u as=3.52p ps=16.88u w=8u l=0.28u
X416 XFE_E.NREGEN.t15 E_REGEN_CLK.t10 VDD.t162 VDD.t161 pfet_03v3 ad=3.52p pd=16.88u as=2.08p ps=8.52u w=8u l=0.28u
X417 FE_E_P.t7 XFE_E.BN.t10 VSS.t230 VSS.t229 nfet_03v3 ad=3.52p pd=16.88u as=2.08p ps=8.52u w=8u l=0.28u
X418 VDD.t51 E_REGEN_CLKB.t9 XFE_E.VREGN.t6 VDD.t50 pfet_03v3 ad=2.08p pd=8.52u as=2.08p ps=8.52u w=8u l=0.28u
X419 VDD.t7 O_REGEN_CLKB.t15 XFE_O.VREGP.t0 VDD.t6 pfet_03v3 ad=2.08p pd=8.52u as=3.52p ps=16.88u w=8u l=0.28u
X420 XFE_E.XN.t27 XFE_E.XP.t56 XFE_E.VREGN.t9 VDD.t304 pfet_03v3 ad=2.08p pd=8.52u as=2.08p ps=8.52u w=8u l=0.28u
X421 VDD.t184 a_n6716_3500.t0 VSS.t146 ppolyf_u r_width=1u r_length=1.4u
X422 XFE_E.SA.t5 E_SENSE_CLK.t4 XFE_E.SB.t5 VDD.t149 pfet_03v3 ad=3.52p pd=16.88u as=2.08p ps=8.52u w=8u l=0.28u
X423 a_n5052_2600.t0 VTHP.t1 a_n6572_3500.t0 VSS.t15 nfet_03v3 ad=0.52p pd=2.52u as=0.88p ps=4.88u w=2u l=0.28u
X424 XFE_E.BN.t5 XFE_E.SXN.t16 VSS.t189 VSS.t188 nfet_03v3 ad=2.08p pd=8.52u as=2.08p ps=8.52u w=8u l=0.28u
X425 a_n6400_n18052.t1 TERM_EN3_N.t0 a_n7300_n18100.t1 VDD.t81 pfet_03v3 ad=2.6p pd=10.52u as=4.4p ps=20.88u w=10u l=0.28u
X426 a_11748_41600.t2 SAMP_CLK_P.t1 a_12148_44200.t4 VSS.t308 nfet_03v3 ad=2.08p pd=8.52u as=3.52p ps=16.88u w=8u l=0.28u
X427 VSS.t24 XFE_O.SXP.t15 XFE_O.BP.t6 VSS.t23 nfet_03v3 ad=2.08p pd=8.52u as=2.08p ps=8.52u w=8u l=0.28u
X428 XFE_O.SXP.t11 XFE_O.XP.t42 VDD.t385 VDD.t384 pfet_03v3 ad=3.52p pd=16.88u as=2.08p ps=8.52u w=8u l=0.28u
X429 XFE_E.XP.t15 E_REGEN_CLK.t20 XFE_E.XN.t21 VDD.t152 pfet_03v3 ad=3.52p pd=16.88u as=2.08p ps=8.52u w=8u l=0.28u
X430 VSS.t116 XFE_E.SXP.t19 XFE_E.BP.t8 VSS.t115 nfet_03v3 ad=2.08p pd=8.52u as=3.52p ps=16.88u w=8u l=0.28u
X431 a_5300_5958.t1 RX_BW_EN_N.t0 RX_RAWN.t3 VDD.t398 pfet_03v3 ad=2.2p pd=10.88u as=2.2p ps=10.88u w=5u l=0.28u
X432 XFE_O.VREGN.t1 O_REGEN_CLKB.t6 VDD.t29 VDD.t28 pfet_03v3 ad=2.08p pd=8.52u as=2.08p ps=8.52u w=8u l=0.28u
X433 XFE_O.XP.t23 XFE_O.XN.t54 XFE_O.VREGP.t11 VDD.t268 pfet_03v3 ad=2.08p pd=8.52u as=2.08p ps=8.52u w=8u l=0.28u
X434 VSS.t130 E_REGEN_CLK.t5 XFE_E.NREGEN.t20 VSS.t7 nfet_03v3 ad=2.08p pd=8.52u as=2.08p ps=8.52u w=8u l=0.28u
X435 VSS.t213 XFE_E.BN.t13 FE_E_P.t4 VSS.t212 nfet_03v3 ad=2.08p pd=8.52u as=2.08p ps=8.52u w=8u l=0.28u
X436 VDD.t399 a_n3600_5641.t5 VSS.t368 ppolyf_u r_width=2u r_length=4.57u
X437 RXP.t6 a_n7300_n18100.t3 VSS.t98 ppolyf_u r_width=1u r_length=1u
X438 VSS.t323 SAMP_BIAS.t3 a_11748_41600.t4 VSS.t322 nfet_03v3 ad=2.6p pd=10.52u as=4.4p ps=20.88u w=10u l=0.28u
X439 a_2148_41600.t5 SAMP_BIAS.t6 VSS.t319 VSS.t318 nfet_03v3 ad=2.6p pd=10.52u as=2.6p ps=10.52u w=10u l=0.28u
X440 VDD.t39 E_REGEN_CLKB.t15 XFE_E.VREGN.t0 VDD.t38 pfet_03v3 ad=2.08p pd=8.52u as=3.52p ps=16.88u w=8u l=0.28u
X441 VSS.t279 XFE_E.XN.t39 XFE_E.SXN.t10 VSS.t278 nfet_03v3 ad=2.08p pd=8.52u as=2.08p ps=8.52u w=8u l=0.28u
X442 FE_O_P.t1 XFE_O.BP.t22 VDD.t75 VDD.t74 pfet_03v3 ad=2.08p pd=8.52u as=2.08p ps=8.52u w=8u l=0.28u
X443 XFE_O.XN.t2 XFE_O.SA.t9 XFE_O.NREGEN.t7 VSS.t89 nfet_03v3 ad=2.08p pd=8.52u as=2.08p ps=8.52u w=8u l=0.28u
X444 XFE_O.BP.t9 XFE_O.SXP.t12 VSS.t155 VSS.t154 nfet_03v3 ad=3.52p pd=16.88u as=2.08p ps=8.52u w=8u l=0.28u
X445 XFE_O.XP.t9 O_REGEN_CLK.t32 VDD.t226 VDD.t203 pfet_03v3 ad=2.08p pd=8.52u as=2.08p ps=8.52u w=8u l=0.28u
X446 VDD.t21 O_REGEN_CLKB.t3 XFE_O.VREGN.t4 VDD.t20 pfet_03v3 ad=2.08p pd=8.52u as=2.08p ps=8.52u w=8u l=0.28u
X447 XFE_O.VREGP.t14 XFE_O.XN.t51 XFE_O.XP.t30 VDD.t96 pfet_03v3 ad=2.08p pd=8.52u as=2.08p ps=8.52u w=8u l=0.28u
X448 a_n3600_5641.t1 RXN.t8 a_n5052_n1000.t0 VSS.t88 nfet_03v3 ad=4.4p pd=20.88u as=2.6p ps=10.52u w=10u l=0.28u
X449 RX_RESTP.t2 a_n1000_22678.t3 a_n852_28800.t7 VSS.t118 nfet_03v3 ad=4.4p pd=20.88u as=2.6p ps=10.52u w=10u l=0.28u
X450 XFE_E.XN.t24 XFE_E.XP.t50 XFE_E.VREGN.t15 VDD.t365 pfet_03v3 ad=3.52p pd=16.88u as=2.08p ps=8.52u w=8u l=0.28u
X451 VSS.t352 XFE_O.XP.t39 XFE_O.SXP.t5 VSS.t351 nfet_03v3 ad=2.08p pd=8.52u as=2.08p ps=8.52u w=8u l=0.28u
X452 VSS.t14 E_SENSE_BOOST.t1 XFE_E.NTAIL.t4 VSS.t13 nfet_03v3 ad=2.08p pd=8.52u as=2.08p ps=8.52u w=8u l=0.28u
X453 XFE_E.NREGEN.t1 XFE_E.SB.t8 XFE_E.XP.t0 VSS.t17 nfet_03v3 ad=2.08p pd=8.52u as=2.08p ps=8.52u w=8u l=0.28u
X454 XFE_O.SXP.t2 XFE_O.XP.t48 VDD.t375 VDD.t374 pfet_03v3 ad=2.08p pd=8.52u as=2.08p ps=8.52u w=8u l=0.28u
X455 XFE_O.BN.t9 XFE_O.SXN.t12 VSS.t366 VSS.t365 nfet_03v3 ad=3.52p pd=16.88u as=2.08p ps=8.52u w=8u l=0.28u
X456 XFE_O.XP.t17 O_REGEN_CLK.t24 XFE_O.XN.t18 VDD.t207 pfet_03v3 ad=2.08p pd=8.52u as=2.08p ps=8.52u w=8u l=0.28u
X457 VDD.t233 O_REGEN_CLK.t29 XFE_O.XP.t12 VDD.t232 pfet_03v3 ad=2.08p pd=8.52u as=2.08p ps=8.52u w=8u l=0.28u
X458 a_n1000_22678.t2 RX_RAWP.t4 a_n852_19400.t1 VSS.t118 nfet_03v3 ad=4.4p pd=20.88u as=2.6p ps=10.52u w=10u l=0.28u
X459 XFE_E.XN.t0 XFE_E.SA.t9 XFE_E.NREGEN.t0 VSS.t16 nfet_03v3 ad=2.08p pd=8.52u as=2.08p ps=8.52u w=8u l=0.28u
X460 VDD.t262 SAMP_E_P.t2 VSS.t221 ppolyf_u r_width=2u r_length=5u
X461 VDD.t177 RX_RAWP.t0 VSS.t137 ppolyf_u r_width=2u r_length=3.43u
X462 a_n7300_n16300.t4 a_n10800_n16172.t3 a_n6400_n16252.t4 VSS.t335 nfet_03v3 ad=4.4p pd=20.88u as=2.6p ps=10.52u w=10u l=0.28u
X463 a_n852_19400.t3 REST_BIAS.t2 VSS.t265 VSS.t258 nfet_03v3 ad=3.12p pd=12.52u as=3.12p ps=12.52u w=12u l=0.28u
X464 a_n10800_n14372.t1 TERM_EN5_N.t2 VSS.t109 VSS.t0 nfet_03v3 ad=0.44p pd=2.88u as=0.44p ps=2.88u w=1u l=0.28u
X465 a_2148_41600.t2 SAMP_CLK_P.t3 a_948_44200.t4 VSS.t306 nfet_03v3 ad=2.08p pd=8.52u as=3.52p ps=16.88u w=8u l=0.28u
X466 VDD.t71 XFE_E.XN.t47 XFE_E.SXN.t1 VDD.t70 pfet_03v3 ad=2.08p pd=8.52u as=2.08p ps=8.52u w=8u l=0.28u
X467 XFE_E.VREGN.t12 XFE_E.XP.t53 XFE_E.XN.t26 VDD.t301 pfet_03v3 ad=2.08p pd=8.52u as=2.08p ps=8.52u w=8u l=0.28u
X468 XFE_E.XP.t34 XFE_E.SB.t11 XFE_E.NREGEN.t33 VSS.t362 nfet_03v3 ad=2.08p pd=8.52u as=2.08p ps=8.52u w=8u l=0.28u
X469 VSS.t151 XFE_E.SXN.t13 XFE_E.BN.t8 VSS.t150 nfet_03v3 ad=2.08p pd=8.52u as=2.08p ps=8.52u w=8u l=0.28u
X470 XFE_O.BP.t3 XFE_O.SXP.t18 VSS.t61 VSS.t60 nfet_03v3 ad=2.08p pd=8.52u as=2.08p ps=8.52u w=8u l=0.28u
X471 VDD.t202 XFE_E.SXN.t21 XFE_E.BN.t0 VDD.t201 pfet_03v3 ad=2.08p pd=8.52u as=3.52p ps=16.88u w=8u l=0.28u
X472 a_2148_n500.t3 RX_BIAS.t1 VSS.t176 VSS.t169 nfet_03v3 ad=2.6p pd=10.52u as=2.6p ps=10.52u w=10u l=0.28u
X473 XFE_O.BP.t1 XFE_O.SXP.t20 VDD.t126 VDD.t125 pfet_03v3 ad=3.52p pd=16.88u as=2.08p ps=8.52u w=8u l=0.28u
X474 a_n5052_n1000.t5 RX_BIAS.t6 VSS.t170 VSS.t169 nfet_03v3 ad=2.6p pd=10.52u as=2.6p ps=10.52u w=10u l=0.28u
X475 a_n10800_n23372.t0 TERM_EN0_N.t3 VDD.t91 VDD.t90 pfet_03v3 ad=0.88p pd=4.88u as=0.88p ps=4.88u w=2u l=0.28u
X476 XFE_E.NREGEN.t23 E_REGEN_CLK.t2 VSS.t133 VSS.t13 nfet_03v3 ad=2.08p pd=8.52u as=2.08p ps=8.52u w=8u l=0.28u
X477 XFE_O.XN.t30 XFE_O.XP.t54 XFE_O.VREGN.t11 VDD.t362 pfet_03v3 ad=2.08p pd=8.52u as=2.08p ps=8.52u w=8u l=0.28u
X478 VDD.t276 XFE_E.BN.t21 FE_E_P.t11 VDD.t275 pfet_03v3 ad=2.08p pd=8.52u as=2.08p ps=8.52u w=8u l=0.28u
X479 XFE_O.BN.t8 XFE_O.SXN.t18 VSS.t333 VSS.t332 nfet_03v3 ad=2.08p pd=8.52u as=2.08p ps=8.52u w=8u l=0.28u
X480 XFE_E.NREGEN.t27 XFE_E.SA.t12 XFE_E.XN.t23 VSS.t277 nfet_03v3 ad=2.08p pd=8.52u as=2.08p ps=8.52u w=8u l=0.28u
X481 a_n852_28800.t1 REST_BIAS.t6 VSS.t259 VSS.t258 nfet_03v3 ad=3.12p pd=12.52u as=3.12p ps=12.52u w=12u l=0.28u
X482 VSS.t236 E_SENSE_CLK.t1 XFE_E.NTAIL.t10 VSS.t235 nfet_03v3 ad=2.08p pd=8.52u as=3.52p ps=16.88u w=8u l=0.28u
X483 XFE_O.XN.t12 O_REGEN_CLK.t14 VDD.t249 VDD.t248 pfet_03v3 ad=2.08p pd=8.52u as=2.08p ps=8.52u w=8u l=0.28u
X484 VDD.t345 XFE_O.BN.t21 FE_O_N.t5 VDD.t344 pfet_03v3 ad=2.08p pd=8.52u as=2.08p ps=8.52u w=8u l=0.28u
X485 VDD.t204 O_SENSE_CLK.t7 XFE_O.SA.t2 VDD.t203 pfet_03v3 ad=2.08p pd=8.52u as=3.52p ps=16.88u w=8u l=0.28u
X486 a_n7300_n19900.t4 a_n10800_n19772.t3 a_n6400_n19852.t4 VSS.t367 nfet_03v3 ad=4.4p pd=20.88u as=2.6p ps=10.52u w=10u l=0.28u
X487 XFE_O.NREGEN.t30 XFE_O.SA.t12 XFE_O.XN.t23 VSS.t292 nfet_03v3 ad=2.08p pd=8.52u as=2.08p ps=8.52u w=8u l=0.28u
X488 XFE_O.XP.t4 XFE_O.SB.t7 XFE_O.NREGEN.t8 VSS.t90 nfet_03v3 ad=3.52p pd=16.88u as=2.08p ps=8.52u w=8u l=0.28u
X489 VSS.t167 RX_BIAS.t9 a_n5052_n1000.t2 VSS.t165 nfet_03v3 ad=2.6p pd=10.52u as=4.4p ps=20.88u w=10u l=0.28u
X490 XFE_E.XP.t21 E_REGEN_CLK.t16 VDD.t160 VDD.t159 pfet_03v3 ad=2.08p pd=8.52u as=2.08p ps=8.52u w=8u l=0.28u
X491 a_n6400_n23452.t0 RXN.t0 VSS.t33 ppolyf_u r_width=1u r_length=2.43u
X492 XFE_O.SXN.t6 XFE_O.XN.t44 VDD.t192 VDD.t191 pfet_03v3 ad=2.08p pd=8.52u as=2.08p ps=8.52u w=8u l=0.28u
X493 a_n6400_n23452.t1 TERM_EN0_N.t0 a_n7157_n23500.t1 VDD.t93 pfet_03v3 ad=2.6p pd=10.52u as=4.4p ps=20.88u w=10u l=0.28u
X494 XFE_O.NTAIL.t5 O_SENSE_CLK.t0 VSS.t183 VSS.t182 nfet_03v3 ad=3.52p pd=16.88u as=2.08p ps=8.52u w=8u l=0.28u
X495 XFE_E.XP.t26 E_REGEN_CLK.t22 XFE_E.XN.t19 VDD.t150 pfet_03v3 ad=2.08p pd=8.52u as=2.08p ps=8.52u w=8u l=0.28u
X496 XFE_O.VREGN.t14 XFE_O.XP.t51 XFE_O.XN.t26 VDD.t336 pfet_03v3 ad=2.08p pd=8.52u as=2.08p ps=8.52u w=8u l=0.28u
X497 XFE_O.SA.t1 SAMP_O_P.t7 XFE_O.NTAIL.t0 VSS.t35 nfet_03v3 ad=3.52p pd=16.88u as=2.08p ps=8.52u w=8u l=0.28u
X498 XFE_O.SB.t5 O_SENSE_CLK.t5 XFE_O.SA.t4 VDD.t207 pfet_03v3 ad=2.08p pd=8.52u as=3.52p ps=16.88u w=8u l=0.28u
X499 VSS.t227 XFE_O.SXN.t15 XFE_O.BN.t5 VSS.t226 nfet_03v3 ad=2.08p pd=8.52u as=2.08p ps=8.52u w=8u l=0.28u
X500 a_n6400_n14452.t3 a_n10800_n14372.t2 a_n7300_n14500.t3 VSS.t285 nfet_03v3 ad=2.6p pd=10.52u as=4.4p ps=20.88u w=10u l=0.28u
X501 XFE_E.XN.t30 XFE_E.XP.t37 XFE_E.NREGEN.t29 VSS.t293 nfet_03v3 ad=2.08p pd=8.52u as=3.52p ps=16.88u w=8u l=0.28u
X502 FE_O_N.t2 XFE_O.BN.t18 VDD.t339 VDD.t338 pfet_03v3 ad=2.08p pd=8.52u as=2.08p ps=8.52u w=8u l=0.28u
X503 XFE_E.SXP.t4 XFE_E.XP.t42 VDD.t307 VDD.t306 pfet_03v3 ad=3.52p pd=16.88u as=2.08p ps=8.52u w=8u l=0.28u
X504 VSS.t217 XFE_E.BN.t15 FE_E_P.t6 VSS.t216 nfet_03v3 ad=2.08p pd=8.52u as=3.52p ps=16.88u w=8u l=0.28u
X505 VSS.t327 SAMP_BIAS.t1 a_11748_41600.t6 VSS.t326 nfet_03v3 ad=2.6p pd=10.52u as=2.6p ps=10.52u w=10u l=0.28u
X506 XFE_O.VREGP.t5 O_REGEN_CLKB.t10 VDD.t15 VDD.t14 pfet_03v3 ad=2.08p pd=8.52u as=2.08p ps=8.52u w=8u l=0.28u
X507 VDD.t312 a_484_3500.t0 VSS.t303 ppolyf_u r_width=1u r_length=1.4u
X508 a_2548_44200.t0 SAMP_E_P.t6 SAMP_E_N.t0 VSS.t71 nfet_03v3 ad=1.56p pd=6.52u as=2.64p ps=12.88u w=6u l=0.28u
X509 VDD.t293 SAMP_O_N.t2 VSS.t280 ppolyf_u r_width=2u r_length=5u
X510 VSS.t75 XFE_E.BP.t11 FE_E_N.t4 VSS.t74 nfet_03v3 ad=2.08p pd=8.52u as=2.08p ps=8.52u w=8u l=0.28u
X511 VSS.t26 XFE_E.XN.t41 XFE_E.SXN.t0 VSS.t25 nfet_03v3 ad=2.08p pd=8.52u as=3.52p ps=16.88u w=8u l=0.28u
X512 FE_O_P.t12 XFE_O.BP.t20 VDD.t359 VDD.t358 pfet_03v3 ad=2.08p pd=8.52u as=2.08p ps=8.52u w=8u l=0.28u
X513 XFE_E.SXN.t6 XFE_E.XN.t44 VDD.t128 VDD.t127 pfet_03v3 ad=2.08p pd=8.52u as=2.08p ps=8.52u w=8u l=0.28u
X514 XFE_E.XN.t16 E_REGEN_CLK.t25 XFE_E.XP.t17 VDD.t147 pfet_03v3 ad=2.08p pd=8.52u as=2.08p ps=8.52u w=8u l=0.28u
R0 TERM_EN0_N.n0 TERM_EN0_N.t1 139.688
R1 TERM_EN0_N.n0 TERM_EN0_N.t0 139.688
R2 TERM_EN0_N.n2 TERM_EN0_N.t3 62.9541
R3 TERM_EN0_N.n1 TERM_EN0_N.t2 49.9184
R4 TERM_EN0_N.n1 TERM_EN0_N.n0 22.445
R5 TERM_EN0_N.n2 TERM_EN0_N.n1 0.8735
R6 TERM_EN0_N TERM_EN0_N.n2 0.539857
R7 TERM_EN1_N.n0 TERM_EN1_N.t1 139.688
R8 TERM_EN1_N.n0 TERM_EN1_N.t0 139.688
R9 TERM_EN1_N.n2 TERM_EN1_N.t3 62.9541
R10 TERM_EN1_N.n1 TERM_EN1_N.t2 49.9184
R11 TERM_EN1_N.n1 TERM_EN1_N.n0 22.445
R12 TERM_EN1_N.n2 TERM_EN1_N.n1 0.8735
R13 TERM_EN1_N TERM_EN1_N.n2 0.539857
R14 TERM_EN2_N.n0 TERM_EN2_N.t1 139.688
R15 TERM_EN2_N.n0 TERM_EN2_N.t0 139.688
R16 TERM_EN2_N.n2 TERM_EN2_N.t3 62.9541
R17 TERM_EN2_N.n1 TERM_EN2_N.t2 49.9184
R18 TERM_EN2_N.n1 TERM_EN2_N.n0 22.445
R19 TERM_EN2_N.n2 TERM_EN2_N.n1 0.8735
R20 TERM_EN2_N TERM_EN2_N.n2 0.539857
R21 TERM_EN3_N.n0 TERM_EN3_N.t1 139.688
R22 TERM_EN3_N.n0 TERM_EN3_N.t0 139.688
R23 TERM_EN3_N.n2 TERM_EN3_N.t3 62.9541
R24 TERM_EN3_N.n1 TERM_EN3_N.t2 49.9184
R25 TERM_EN3_N.n1 TERM_EN3_N.n0 22.445
R26 TERM_EN3_N.n2 TERM_EN3_N.n1 0.8735
R27 TERM_EN3_N TERM_EN3_N.n2 0.539857
R28 TERM_EN4_N.n0 TERM_EN4_N.t1 139.688
R29 TERM_EN4_N.n0 TERM_EN4_N.t0 139.688
R30 TERM_EN4_N.n2 TERM_EN4_N.t3 62.9541
R31 TERM_EN4_N.n1 TERM_EN4_N.t2 49.9184
R32 TERM_EN4_N.n1 TERM_EN4_N.n0 22.445
R33 TERM_EN4_N.n2 TERM_EN4_N.n1 0.8735
R34 TERM_EN4_N TERM_EN4_N.n2 0.539857
R35 TERM_EN5_N.n0 TERM_EN5_N.t1 139.688
R36 TERM_EN5_N.n0 TERM_EN5_N.t0 139.688
R37 TERM_EN5_N.n2 TERM_EN5_N.t3 62.9541
R38 TERM_EN5_N.n1 TERM_EN5_N.t2 49.9184
R39 TERM_EN5_N.n1 TERM_EN5_N.n0 22.445
R40 TERM_EN5_N.n2 TERM_EN5_N.n1 0.8735
R41 TERM_EN5_N TERM_EN5_N.n2 0.539857
R42 TERM_EN6_N.n0 TERM_EN6_N.t1 139.688
R43 TERM_EN6_N.n0 TERM_EN6_N.t0 139.688
R44 TERM_EN6_N.n2 TERM_EN6_N.t3 62.9541
R45 TERM_EN6_N.n1 TERM_EN6_N.t2 49.9184
R46 TERM_EN6_N.n1 TERM_EN6_N.n0 22.445
R47 TERM_EN6_N.n2 TERM_EN6_N.n1 0.8735
R48 TERM_EN6_N TERM_EN6_N.n2 0.539857
R49 RXN.n0 RXN.t8 139.689
R50 RXN.n0 RXN.t9 139.689
R51 RXN.n1 RXN.n0 32.5563
R52 RXN.n2 RXN.t0 16.451
R53 RXN.n7 RXN.t5 15.7257
R54 RXN.n6 RXN.t3 15.7257
R55 RXN.n5 RXN.t2 15.7257
R56 RXN.n4 RXN.t1 15.7257
R57 RXN.n3 RXN.t4 15.7257
R58 RXN.n2 RXN.t7 15.641
R59 RXN.n1 RXN.t6 12.4583
R60 RXN.n3 RXN.n2 0.8105
R61 RXN.n4 RXN.n3 0.8105
R62 RXN.n5 RXN.n4 0.8105
R63 RXN.n6 RXN.n5 0.8105
R64 RXN.n7 RXN.n6 0.8105
R65 RXN RXN.n7 0.6305
R66 RXN RXN.n1 0.1805
R67 RXP.n0 RXP.t8 139.689
R68 RXP.n0 RXP.t9 139.689
R69 RXP.n1 RXP.n0 32.5563
R70 RXP.n2 RXP.t7 16.451
R71 RXP.n3 RXP.t5 15.7257
R72 RXP.n4 RXP.t6 15.7257
R73 RXP.n5 RXP.t2 15.7257
R74 RXP.n6 RXP.t1 15.7257
R75 RXP.n7 RXP.t3 15.7257
R76 RXP.n2 RXP.t0 15.641
R77 RXP.n1 RXP.t4 12.4583
R78 RXP.n3 RXP.n2 0.8105
R79 RXP.n4 RXP.n3 0.8105
R80 RXP.n5 RXP.n4 0.8105
R81 RXP.n6 RXP.n5 0.8105
R82 RXP.n7 RXP.n6 0.8105
R83 RXP RXP.n7 0.6305
R84 RXP RXP.n1 0.1805
R85 RX_BIAS.n4 RX_BIAS.t4 139.702
R86 RX_BIAS.n0 RX_BIAS.t0 139.702
R87 RX_BIAS.n15 RX_BIAS.t9 139.702
R88 RX_BIAS.n11 RX_BIAS.t5 139.702
R89 RX_BIAS.n1 RX_BIAS.t1 135.246
R90 RX_BIAS.n2 RX_BIAS.t2 135.246
R91 RX_BIAS.n3 RX_BIAS.t3 135.246
R92 RX_BIAS.n12 RX_BIAS.t6 135.246
R93 RX_BIAS.n13 RX_BIAS.t7 135.246
R94 RX_BIAS.n14 RX_BIAS.t8 135.246
R95 RX_BIAS.n6 RX_BIAS.t10 35.4171
R96 RX_BIAS.n9 RX_BIAS.t13 35.4171
R97 RX_BIAS.n7 RX_BIAS.t11 30.9603
R98 RX_BIAS.n8 RX_BIAS.t12 30.9603
R99 RX_BIAS.n17 RX_BIAS.n10 21.4384
R100 RX_BIAS.n18 RX_BIAS.n5 18.9479
R101 RX_BIAS.n5 RX_BIAS.n2 18.4942
R102 RX_BIAS.n16 RX_BIAS.n13 18.4942
R103 RX_BIAS.n17 RX_BIAS.n16 18.0005
R104 RX_BIAS.n8 RX_BIAS.n7 11.6805
R105 RX_BIAS.n2 RX_BIAS.n1 11.6805
R106 RX_BIAS.n3 RX_BIAS.n2 11.6805
R107 RX_BIAS.n13 RX_BIAS.n12 11.6805
R108 RX_BIAS.n14 RX_BIAS.n13 11.6805
R109 RX_BIAS RX_BIAS.n18 7.56892
R110 RX_BIAS.n5 RX_BIAS.n0 7.16487
R111 RX_BIAS.n5 RX_BIAS.n4 7.16487
R112 RX_BIAS.n16 RX_BIAS.n11 7.16487
R113 RX_BIAS.n16 RX_BIAS.n15 7.16487
R114 RX_BIAS.n10 RX_BIAS.n6 7.09873
R115 RX_BIAS.n10 RX_BIAS.n9 7.09873
R116 RX_BIAS.n7 RX_BIAS.n6 4.42851
R117 RX_BIAS.n9 RX_BIAS.n8 4.42851
R118 RX_BIAS.n1 RX_BIAS.n0 4.42851
R119 RX_BIAS.n4 RX_BIAS.n3 4.42851
R120 RX_BIAS.n12 RX_BIAS.n11 4.42851
R121 RX_BIAS.n15 RX_BIAS.n14 4.42851
R122 RX_BIAS.n18 RX_BIAS.n17 0.947868
R123 VTHN.n0 VTHN.t0 35.4171
R124 VTHN.n0 VTHN.t1 35.3883
R125 VTHN VTHN.n0 35.0111
R126 VTHP.n0 VTHP.t1 35.4171
R127 VTHP.n0 VTHP.t0 35.3883
R128 VTHP VTHP.n0 34.2271
R129 RX_BW_EN_N.n0 RX_BW_EN_N.t0 104.718
R130 RX_BW_EN_N.n2 RX_BW_EN_N.t3 102.35
R131 RX_BW_EN_N.n1 RX_BW_EN_N.t2 102.35
R132 RX_BW_EN_N.n0 RX_BW_EN_N.t1 102.35
R133 RX_BW_EN_N RX_BW_EN_N.n2 2.55971
R134 RX_BW_EN_N.n2 RX_BW_EN_N.n1 2.36892
R135 RX_BW_EN_N.n1 RX_BW_EN_N.n0 1.89524
R136 RX_RAWN.n0 RX_RAWN.t4 139.689
R137 RX_RAWN.n0 RX_RAWN.t5 139.689
R138 RX_RAWN RX_RAWN.n0 36.4661
R139 RX_RAWN.n3 RX_RAWN.t0 12.5711
R140 RX_RAWN.n2 RX_RAWN.t3 10.6142
R141 RX_RAWN RX_RAWN.n3 6.39524
R142 RX_RAWN.n1 RX_RAWN.t2 6.0676
R143 RX_RAWN.n1 RX_RAWN.t1 6.06436
R144 RX_RAWN.n2 RX_RAWN.n1 3.78254
R145 RX_RAWN.n3 RX_RAWN.n2 0.491409
R146 RX_RAWP.n0 RX_RAWP.t4 139.689
R147 RX_RAWP.n0 RX_RAWP.t5 139.689
R148 RX_RAWP RX_RAWP.n0 36.3761
R149 RX_RAWP.n3 RX_RAWP.t0 12.5711
R150 RX_RAWP.n2 RX_RAWP.t3 10.6142
R151 RX_RAWP RX_RAWP.n3 6.39524
R152 RX_RAWP.n1 RX_RAWP.t1 6.0676
R153 RX_RAWP.n1 RX_RAWP.t2 6.06436
R154 RX_RAWP.n2 RX_RAWP.n1 3.78254
R155 RX_RAWP.n3 RX_RAWP.n2 0.491409
R156 REST_BIAS.n8 REST_BIAS.t3 165.774
R157 REST_BIAS.n5 REST_BIAS.t0 165.774
R158 REST_BIAS.n0 REST_BIAS.t4 165.774
R159 REST_BIAS.n3 REST_BIAS.t7 165.774
R160 REST_BIAS.n6 REST_BIAS.t1 161.317
R161 REST_BIAS.n7 REST_BIAS.t2 161.317
R162 REST_BIAS.n1 REST_BIAS.t5 161.317
R163 REST_BIAS.n2 REST_BIAS.t6 161.317
R164 REST_BIAS.n10 REST_BIAS.n4 19.0663
R165 REST_BIAS.n10 REST_BIAS.n9 13.5005
R166 REST_BIAS.n7 REST_BIAS.n6 11.6805
R167 REST_BIAS.n2 REST_BIAS.n1 11.6805
R168 REST_BIAS.n9 REST_BIAS.n5 7.10487
R169 REST_BIAS.n9 REST_BIAS.n8 7.10487
R170 REST_BIAS.n4 REST_BIAS.n0 7.10487
R171 REST_BIAS.n4 REST_BIAS.n3 7.10487
R172 REST_BIAS REST_BIAS.n10 6.38708
R173 REST_BIAS.n6 REST_BIAS.n5 4.42851
R174 REST_BIAS.n8 REST_BIAS.n7 4.42851
R175 REST_BIAS.n1 REST_BIAS.n0 4.42851
R176 REST_BIAS.n3 REST_BIAS.n2 4.42851
R177 SAMP_BIAS.n3 SAMP_BIAS.t3 139.702
R178 SAMP_BIAS.n0 SAMP_BIAS.t0 139.702
R179 SAMP_BIAS.n5 SAMP_BIAS.t4 139.702
R180 SAMP_BIAS.n8 SAMP_BIAS.t7 139.702
R181 SAMP_BIAS.n1 SAMP_BIAS.t1 135.246
R182 SAMP_BIAS.n2 SAMP_BIAS.t2 135.246
R183 SAMP_BIAS.n6 SAMP_BIAS.t5 135.246
R184 SAMP_BIAS.n7 SAMP_BIAS.t6 135.246
R185 SAMP_BIAS.n10 SAMP_BIAS.n4 19.1847
R186 SAMP_BIAS.n10 SAMP_BIAS.n9 13.5005
R187 SAMP_BIAS SAMP_BIAS.n10 12.8674
R188 SAMP_BIAS.n2 SAMP_BIAS.n1 11.6805
R189 SAMP_BIAS.n7 SAMP_BIAS.n6 11.6805
R190 SAMP_BIAS.n4 SAMP_BIAS.n0 7.10487
R191 SAMP_BIAS.n4 SAMP_BIAS.n3 7.10487
R192 SAMP_BIAS.n9 SAMP_BIAS.n5 7.10487
R193 SAMP_BIAS.n9 SAMP_BIAS.n8 7.10487
R194 SAMP_BIAS.n1 SAMP_BIAS.n0 4.42851
R195 SAMP_BIAS.n3 SAMP_BIAS.n2 4.42851
R196 SAMP_BIAS.n6 SAMP_BIAS.n5 4.42851
R197 SAMP_BIAS.n8 SAMP_BIAS.n7 4.42851
R198 SAMP_CLK_N.n1 SAMP_CLK_N.t1 113.618
R199 SAMP_CLK_N.n1 SAMP_CLK_N.t0 113.618
R200 SAMP_CLK_N.n0 SAMP_CLK_N.t3 113.618
R201 SAMP_CLK_N.n0 SAMP_CLK_N.t2 113.618
R202 SAMP_CLK_N.n2 SAMP_CLK_N.n1 25.1703
R203 SAMP_CLK_N.n2 SAMP_CLK_N.n0 20.9071
R204 SAMP_CLK_N SAMP_CLK_N.n2 13.1872
R205 SAMP_CLK_P.n1 SAMP_CLK_P.t1 113.618
R206 SAMP_CLK_P.n1 SAMP_CLK_P.t0 113.618
R207 SAMP_CLK_P.n0 SAMP_CLK_P.t3 113.618
R208 SAMP_CLK_P.n0 SAMP_CLK_P.t2 113.618
R209 SAMP_CLK_P.n2 SAMP_CLK_P.n1 28.3203
R210 SAMP_CLK_P.n2 SAMP_CLK_P.n0 25.1624
R211 SAMP_CLK_P SAMP_CLK_P.n2 5.7165
R212 RX_RESTP.n1 RX_RESTP.t5 87.5461
R213 RX_RESTP.n1 RX_RESTP.t6 87.5461
R214 RX_RESTP.n0 RX_RESTP.t3 87.5461
R215 RX_RESTP.n0 RX_RESTP.t4 87.5461
R216 RX_RESTP.n2 RX_RESTP.n0 31.2488
R217 RX_RESTP.n2 RX_RESTP.n1 25.5646
R218 RX_RESTP RX_RESTP.n2 14.1979
R219 RX_RESTP.n4 RX_RESTP.t0 12.57
R220 RX_RESTP RX_RESTP.n4 11.8991
R221 RX_RESTP.n3 RX_RESTP.t1 6.0613
R222 RX_RESTP.n3 RX_RESTP.t2 6.0613
R223 RX_RESTP.n4 RX_RESTP.n3 2.77532
R224 RX_RESTN.n0 RX_RESTN.t5 87.5461
R225 RX_RESTN.n0 RX_RESTN.t6 87.5461
R226 RX_RESTN.n1 RX_RESTN.t3 87.5461
R227 RX_RESTN.n1 RX_RESTN.t4 87.5461
R228 RX_RESTN.n2 RX_RESTN.n1 22.0262
R229 RX_RESTN.n2 RX_RESTN.n0 16.342
R230 RX_RESTN.n4 RX_RESTN.t0 12.57
R231 RX_RESTN RX_RESTN.n4 9.30958
R232 RX_RESTN RX_RESTN.n2 9.17813
R233 RX_RESTN.n3 RX_RESTN.t2 6.0613
R234 RX_RESTN.n3 RX_RESTN.t1 6.0613
R235 RX_RESTN.n4 RX_RESTN.n3 2.77532
R236 O_SENSE_BOOST.n3 O_SENSE_BOOST.t5 113.632
R237 O_SENSE_BOOST.n0 O_SENSE_BOOST.t0 109.174
R238 O_SENSE_BOOST.n7 O_SENSE_BOOST.t1 109.174
R239 O_SENSE_BOOST.n6 O_SENSE_BOOST.t2 109.174
R240 O_SENSE_BOOST.n5 O_SENSE_BOOST.t3 109.174
R241 O_SENSE_BOOST.n2 O_SENSE_BOOST.t4 109.174
R242 O_SENSE_BOOST O_SENSE_BOOST.n9 34.2009
R243 O_SENSE_BOOST.n9 O_SENSE_BOOST.n0 18.5636
R244 O_SENSE_BOOST.n8 O_SENSE_BOOST.n7 18.4942
R245 O_SENSE_BOOST.n6 O_SENSE_BOOST.n1 18.4942
R246 O_SENSE_BOOST.n5 O_SENSE_BOOST.n4 18.4942
R247 O_SENSE_BOOST.n7 O_SENSE_BOOST.n0 11.6805
R248 O_SENSE_BOOST.n7 O_SENSE_BOOST.n6 11.6805
R249 O_SENSE_BOOST.n6 O_SENSE_BOOST.n5 11.6805
R250 O_SENSE_BOOST.n5 O_SENSE_BOOST.n2 11.6805
R251 O_SENSE_BOOST.n4 O_SENSE_BOOST.n3 7.17687
R252 O_SENSE_BOOST.n3 O_SENSE_BOOST.n2 4.42851
R253 O_SENSE_BOOST.n4 O_SENSE_BOOST.n1 0.1205
R254 O_SENSE_BOOST.n8 O_SENSE_BOOST.n1 0.1205
R255 O_SENSE_BOOST.n9 O_SENSE_BOOST.n8 0.0485
R256 SAMP_O_N.n10 SAMP_O_N.t7 113.618
R257 SAMP_O_N.n10 SAMP_O_N.t8 113.618
R258 SAMP_O_N.n1 SAMP_O_N.t5 87.5461
R259 SAMP_O_N.n1 SAMP_O_N.t6 87.5461
R260 SAMP_O_N SAMP_O_N.n10 54.516
R261 SAMP_O_N.n2 SAMP_O_N.n1 26.3217
R262 SAMP_O_N SAMP_O_N.n9 14.2502
R263 SAMP_O_N.n9 SAMP_O_N.t2 12.4596
R264 SAMP_O_N.n0 SAMP_O_N.t1 5.96544
R265 SAMP_O_N.n0 SAMP_O_N.t0 5.9622
R266 SAMP_O_N.n5 SAMP_O_N.t3 5.87051
R267 SAMP_O_N.n4 SAMP_O_N.t4 5.87051
R268 SAMP_O_N.n4 SAMP_O_N.n3 4.5005
R269 SAMP_O_N.n6 SAMP_O_N.n5 4.5005
R270 SAMP_O_N.n8 SAMP_O_N.n0 2.56391
R271 SAMP_O_N.n9 SAMP_O_N.n8 0.8805
R272 SAMP_O_N.n7 SAMP_O_N.n2 0.419
R273 SAMP_O_N.n8 SAMP_O_N.n7 0.2415
R274 SAMP_O_N.n5 SAMP_O_N.n4 0.189974
R275 SAMP_O_N.n6 SAMP_O_N.n3 0.1605
R276 SAMP_O_N.n7 SAMP_O_N.n6 0.0795
R277 SAMP_O_N.n3 SAMP_O_N.n2 0.0740593
R278 SAMP_O_P.n10 SAMP_O_P.t7 113.618
R279 SAMP_O_P.n10 SAMP_O_P.t8 113.618
R280 SAMP_O_P.n0 SAMP_O_P.t5 87.5461
R281 SAMP_O_P.n0 SAMP_O_P.t6 87.5461
R282 SAMP_O_P SAMP_O_P.n10 49.414
R283 SAMP_O_P.n1 SAMP_O_P.n0 35.3132
R284 SAMP_O_P SAMP_O_P.n9 14.2502
R285 SAMP_O_P.n9 SAMP_O_P.t2 12.4596
R286 SAMP_O_P.n7 SAMP_O_P.t3 5.96544
R287 SAMP_O_P.n7 SAMP_O_P.t4 5.9622
R288 SAMP_O_P.n3 SAMP_O_P.t0 5.87051
R289 SAMP_O_P.n4 SAMP_O_P.t1 5.87051
R290 SAMP_O_P.n5 SAMP_O_P.n4 4.5005
R291 SAMP_O_P.n3 SAMP_O_P.n2 4.5005
R292 SAMP_O_P.n8 SAMP_O_P.n7 2.56391
R293 SAMP_O_P.n9 SAMP_O_P.n8 0.8805
R294 SAMP_O_P.n6 SAMP_O_P.n1 0.419
R295 SAMP_O_P.n8 SAMP_O_P.n6 0.2415
R296 SAMP_O_P.n4 SAMP_O_P.n3 0.189974
R297 SAMP_O_P.n5 SAMP_O_P.n2 0.1605
R298 SAMP_O_P.n6 SAMP_O_P.n5 0.0795
R299 SAMP_O_P.n2 SAMP_O_P.n1 0.0405
R300 E_SENSE_BOOST.n3 E_SENSE_BOOST.t0 113.632
R301 E_SENSE_BOOST.n4 E_SENSE_BOOST.t1 109.174
R302 E_SENSE_BOOST.n5 E_SENSE_BOOST.t2 109.174
R303 E_SENSE_BOOST.n6 E_SENSE_BOOST.t3 109.174
R304 E_SENSE_BOOST.n7 E_SENSE_BOOST.t4 109.174
R305 E_SENSE_BOOST.n8 E_SENSE_BOOST.t5 109.174
R306 E_SENSE_BOOST E_SENSE_BOOST.n9 34.2009
R307 E_SENSE_BOOST.n9 E_SENSE_BOOST.n8 18.5636
R308 E_SENSE_BOOST.n5 E_SENSE_BOOST.n2 18.4942
R309 E_SENSE_BOOST.n6 E_SENSE_BOOST.n1 18.4942
R310 E_SENSE_BOOST.n7 E_SENSE_BOOST.n0 18.4942
R311 E_SENSE_BOOST.n5 E_SENSE_BOOST.n4 11.6805
R312 E_SENSE_BOOST.n6 E_SENSE_BOOST.n5 11.6805
R313 E_SENSE_BOOST.n7 E_SENSE_BOOST.n6 11.6805
R314 E_SENSE_BOOST.n8 E_SENSE_BOOST.n7 11.6805
R315 E_SENSE_BOOST.n3 E_SENSE_BOOST.n2 7.17687
R316 E_SENSE_BOOST.n4 E_SENSE_BOOST.n3 4.42851
R317 E_SENSE_BOOST.n1 E_SENSE_BOOST.n0 0.1205
R318 E_SENSE_BOOST.n2 E_SENSE_BOOST.n1 0.1205
R319 E_SENSE_BOOST.n9 E_SENSE_BOOST.n0 0.0485
R320 SAMP_E_N.n10 SAMP_E_N.t7 113.618
R321 SAMP_E_N.n10 SAMP_E_N.t8 113.618
R322 SAMP_E_N.n1 SAMP_E_N.t5 87.5461
R323 SAMP_E_N.n1 SAMP_E_N.t6 87.5461
R324 SAMP_E_N SAMP_E_N.n10 49.414
R325 SAMP_E_N.n2 SAMP_E_N.n1 26.3484
R326 SAMP_E_N SAMP_E_N.n9 14.2502
R327 SAMP_E_N.n9 SAMP_E_N.t2 12.4596
R328 SAMP_E_N.n0 SAMP_E_N.t4 5.96544
R329 SAMP_E_N.n0 SAMP_E_N.t3 5.9622
R330 SAMP_E_N.n5 SAMP_E_N.t1 5.87051
R331 SAMP_E_N.n4 SAMP_E_N.t0 5.87051
R332 SAMP_E_N.n4 SAMP_E_N.n3 4.5005
R333 SAMP_E_N.n6 SAMP_E_N.n5 4.5005
R334 SAMP_E_N.n8 SAMP_E_N.n0 2.56391
R335 SAMP_E_N.n9 SAMP_E_N.n8 0.8805
R336 SAMP_E_N.n7 SAMP_E_N.n2 0.419
R337 SAMP_E_N.n8 SAMP_E_N.n7 0.2415
R338 SAMP_E_N.n5 SAMP_E_N.n4 0.189974
R339 SAMP_E_N.n6 SAMP_E_N.n3 0.1605
R340 SAMP_E_N.n7 SAMP_E_N.n6 0.0795
R341 SAMP_E_N.n3 SAMP_E_N.n2 0.0405
R342 SAMP_E_P.n10 SAMP_E_P.t7 113.618
R343 SAMP_E_P.n10 SAMP_E_P.t8 113.618
R344 SAMP_E_P.n0 SAMP_E_P.t5 87.5461
R345 SAMP_E_P.n0 SAMP_E_P.t6 87.5461
R346 SAMP_E_P SAMP_E_P.n10 54.516
R347 SAMP_E_P.n1 SAMP_E_P.n0 35.155
R348 SAMP_E_P SAMP_E_P.n9 14.2502
R349 SAMP_E_P.n9 SAMP_E_P.t2 12.4596
R350 SAMP_E_P.n7 SAMP_E_P.t3 5.96544
R351 SAMP_E_P.n7 SAMP_E_P.t4 5.9622
R352 SAMP_E_P.n3 SAMP_E_P.t0 5.87051
R353 SAMP_E_P.n4 SAMP_E_P.t1 5.87051
R354 SAMP_E_P.n5 SAMP_E_P.n4 4.5005
R355 SAMP_E_P.n3 SAMP_E_P.n2 4.5005
R356 SAMP_E_P.n8 SAMP_E_P.n7 2.56391
R357 SAMP_E_P.n9 SAMP_E_P.n8 0.8805
R358 SAMP_E_P.n6 SAMP_E_P.n1 0.419
R359 SAMP_E_P.n8 SAMP_E_P.n6 0.2415
R360 SAMP_E_P.n4 SAMP_E_P.n3 0.189974
R361 SAMP_E_P.n5 SAMP_E_P.n2 0.1605
R362 SAMP_E_P.n6 SAMP_E_P.n5 0.0795
R363 SAMP_E_P.n2 SAMP_E_P.n1 0.0740593
R364 FE_O_N FE_O_N.n12 11.3292
R365 FE_O_N.n12 FE_O_N.n11 9.42986
R366 FE_O_N.n12 FE_O_N.n6 7.01407
R367 FE_O_N.n8 FE_O_N.t10 5.7796
R368 FE_O_N.n1 FE_O_N.t8 5.73764
R369 FE_O_N.n5 FE_O_N.t1 5.73764
R370 FE_O_N.n11 FE_O_N.t7 5.59012
R371 FE_O_N.n8 FE_O_N.n7 5.38537
R372 FE_O_N.n10 FE_O_N.n9 5.38537
R373 FE_O_N.n1 FE_O_N.n0 5.32067
R374 FE_O_N.n3 FE_O_N.n2 5.32067
R375 FE_O_N.n5 FE_O_N.n4 5.32067
R376 FE_O_N.n0 FE_O_N.t2 0.228
R377 FE_O_N.n0 FE_O_N.t9 0.228
R378 FE_O_N.n2 FE_O_N.t4 0.228
R379 FE_O_N.n2 FE_O_N.t3 0.228
R380 FE_O_N.n4 FE_O_N.t0 0.228
R381 FE_O_N.n4 FE_O_N.t5 0.228
R382 FE_O_N.n7 FE_O_N.t12 0.20525
R383 FE_O_N.n7 FE_O_N.t11 0.20525
R384 FE_O_N.n9 FE_O_N.t6 0.20525
R385 FE_O_N.n9 FE_O_N.t13 0.20525
R386 FE_O_N.n11 FE_O_N.n10 0.189974
R387 FE_O_N.n10 FE_O_N.n8 0.189974
R388 FE_O_N.n3 FE_O_N.n1 0.189974
R389 FE_O_N.n6 FE_O_N.n5 0.0952368
R390 FE_O_N.n6 FE_O_N.n3 0.0952368
R391 FE_O_P FE_O_P.n12 11.0162
R392 FE_O_P.n12 FE_O_P.n11 8.81407
R393 FE_O_P.n12 FE_O_P.n6 7.46407
R394 FE_O_P.n8 FE_O_P.t4 5.7796
R395 FE_O_P.n1 FE_O_P.t5 5.73764
R396 FE_O_P.n5 FE_O_P.t13 5.73764
R397 FE_O_P.n11 FE_O_P.t8 5.61381
R398 FE_O_P.n10 FE_O_P.n9 5.38537
R399 FE_O_P.n8 FE_O_P.n7 5.38537
R400 FE_O_P.n1 FE_O_P.n0 5.32067
R401 FE_O_P.n3 FE_O_P.n2 5.32067
R402 FE_O_P.n5 FE_O_P.n4 5.32067
R403 FE_O_P.n0 FE_O_P.t7 0.228
R404 FE_O_P.n0 FE_O_P.t6 0.228
R405 FE_O_P.n2 FE_O_P.t12 0.228
R406 FE_O_P.n2 FE_O_P.t11 0.228
R407 FE_O_P.n4 FE_O_P.t1 0.228
R408 FE_O_P.n4 FE_O_P.t0 0.228
R409 FE_O_P.n9 FE_O_P.t10 0.20525
R410 FE_O_P.n9 FE_O_P.t9 0.20525
R411 FE_O_P.n7 FE_O_P.t3 0.20525
R412 FE_O_P.n7 FE_O_P.t2 0.20525
R413 FE_O_P.n10 FE_O_P.n8 0.189974
R414 FE_O_P.n3 FE_O_P.n1 0.189974
R415 FE_O_P.n11 FE_O_P.n10 0.166289
R416 FE_O_P.n6 FE_O_P.n5 0.0952368
R417 FE_O_P.n6 FE_O_P.n3 0.0952368
R418 FE_E_N FE_E_N.n12 11.0162
R419 FE_E_N.n12 FE_E_N.n11 8.81407
R420 FE_E_N.n12 FE_E_N.n6 7.46407
R421 FE_E_N.n8 FE_E_N.t13 5.7796
R422 FE_E_N.n1 FE_E_N.t2 5.73764
R423 FE_E_N.n3 FE_E_N.t3 5.73764
R424 FE_E_N.n11 FE_E_N.t1 5.61381
R425 FE_E_N.n8 FE_E_N.n7 5.38537
R426 FE_E_N.n10 FE_E_N.n9 5.38537
R427 FE_E_N.n1 FE_E_N.n0 5.32067
R428 FE_E_N.n5 FE_E_N.n4 5.32067
R429 FE_E_N.n3 FE_E_N.n2 5.32067
R430 FE_E_N.n0 FE_E_N.t10 0.228
R431 FE_E_N.n0 FE_E_N.t9 0.228
R432 FE_E_N.n4 FE_E_N.t8 0.228
R433 FE_E_N.n4 FE_E_N.t7 0.228
R434 FE_E_N.n2 FE_E_N.t12 0.228
R435 FE_E_N.n2 FE_E_N.t11 0.228
R436 FE_E_N.n7 FE_E_N.t5 0.20525
R437 FE_E_N.n7 FE_E_N.t4 0.20525
R438 FE_E_N.n9 FE_E_N.t0 0.20525
R439 FE_E_N.n9 FE_E_N.t6 0.20525
R440 FE_E_N.n10 FE_E_N.n8 0.189974
R441 FE_E_N.n5 FE_E_N.n3 0.189974
R442 FE_E_N.n11 FE_E_N.n10 0.166289
R443 FE_E_N.n6 FE_E_N.n5 0.0952368
R444 FE_E_N.n6 FE_E_N.n1 0.0952368
R445 FE_E_P FE_E_P.n12 11.3292
R446 FE_E_P.n12 FE_E_P.n11 9.42986
R447 FE_E_P.n12 FE_E_P.n6 7.01407
R448 FE_E_P.n8 FE_E_P.t6 5.7796
R449 FE_E_P.n1 FE_E_P.t12 5.73764
R450 FE_E_P.n3 FE_E_P.t1 5.73764
R451 FE_E_P.n11 FE_E_P.t7 5.59012
R452 FE_E_P.n10 FE_E_P.n9 5.38537
R453 FE_E_P.n8 FE_E_P.n7 5.38537
R454 FE_E_P.n1 FE_E_P.n0 5.32067
R455 FE_E_P.n5 FE_E_P.n4 5.32067
R456 FE_E_P.n3 FE_E_P.n2 5.32067
R457 FE_E_P.n0 FE_E_P.t2 0.228
R458 FE_E_P.n0 FE_E_P.t13 0.228
R459 FE_E_P.n4 FE_E_P.t10 0.228
R460 FE_E_P.n4 FE_E_P.t3 0.228
R461 FE_E_P.n2 FE_E_P.t0 0.228
R462 FE_E_P.n2 FE_E_P.t11 0.228
R463 FE_E_P.n9 FE_E_P.t9 0.20525
R464 FE_E_P.n9 FE_E_P.t8 0.20525
R465 FE_E_P.n7 FE_E_P.t5 0.20525
R466 FE_E_P.n7 FE_E_P.t4 0.20525
R467 FE_E_P.n10 FE_E_P.n8 0.189974
R468 FE_E_P.n11 FE_E_P.n10 0.189974
R469 FE_E_P.n5 FE_E_P.n3 0.189974
R470 FE_E_P.n6 FE_E_P.n5 0.0952368
R471 FE_E_P.n6 FE_E_P.n1 0.0952368
R472 O_SENSE_CLK.n0 O_SENSE_CLK.t2 113.632
R473 O_SENSE_CLK.n1 O_SENSE_CLK.t5 113.632
R474 O_SENSE_CLK.n5 O_SENSE_CLK.t6 113.632
R475 O_SENSE_CLK.n3 O_SENSE_CLK.t0 113.618
R476 O_SENSE_CLK.n3 O_SENSE_CLK.t1 113.618
R477 O_SENSE_CLK.n0 O_SENSE_CLK.t3 113.603
R478 O_SENSE_CLK.n1 O_SENSE_CLK.t4 113.603
R479 O_SENSE_CLK.n5 O_SENSE_CLK.t7 113.603
R480 O_SENSE_CLK.n6 O_SENSE_CLK.n5 35.4506
R481 O_SENSE_CLK.n4 O_SENSE_CLK.n2 22.7641
R482 O_SENSE_CLK O_SENSE_CLK.n6 18.6466
R483 O_SENSE_CLK.n4 O_SENSE_CLK.n3 16.0613
R484 O_SENSE_CLK.n6 O_SENSE_CLK.n4 9.38566
R485 O_SENSE_CLK.n2 O_SENSE_CLK.n0 7.88487
R486 O_SENSE_CLK.n2 O_SENSE_CLK.n1 7.88487
R487 E_SENSE_CLK.n5 E_SENSE_CLK.t3 113.632
R488 E_SENSE_CLK.n0 E_SENSE_CLK.t4 113.632
R489 E_SENSE_CLK.n1 E_SENSE_CLK.t7 113.632
R490 E_SENSE_CLK.n3 E_SENSE_CLK.t0 113.618
R491 E_SENSE_CLK.n3 E_SENSE_CLK.t1 113.618
R492 E_SENSE_CLK.n5 E_SENSE_CLK.t2 113.603
R493 E_SENSE_CLK.n0 E_SENSE_CLK.t5 113.603
R494 E_SENSE_CLK.n1 E_SENSE_CLK.t6 113.603
R495 E_SENSE_CLK.n6 E_SENSE_CLK.n5 35.4506
R496 E_SENSE_CLK.n4 E_SENSE_CLK.n2 22.7641
R497 E_SENSE_CLK E_SENSE_CLK.n6 18.6466
R498 E_SENSE_CLK.n4 E_SENSE_CLK.n3 16.0613
R499 E_SENSE_CLK.n6 E_SENSE_CLK.n4 9.38566
R500 E_SENSE_CLK.n2 E_SENSE_CLK.n0 7.88487
R501 E_SENSE_CLK.n2 E_SENSE_CLK.n1 7.88487
R502 O_REGEN_CLK.t12 O_REGEN_CLK.n72 127.788
R503 O_REGEN_CLK.t35 O_REGEN_CLK.n32 127.788
R504 O_REGEN_CLK.t20 O_REGEN_CLK.n11 127.788
R505 O_REGEN_CLK.t19 O_REGEN_CLK.n61 127.668
R506 O_REGEN_CLK.n72 O_REGEN_CLK.t13 127.668
R507 O_REGEN_CLK.n71 O_REGEN_CLK.t14 127.668
R508 O_REGEN_CLK.n70 O_REGEN_CLK.t15 127.668
R509 O_REGEN_CLK.n69 O_REGEN_CLK.t16 127.668
R510 O_REGEN_CLK.n68 O_REGEN_CLK.t17 127.668
R511 O_REGEN_CLK.n67 O_REGEN_CLK.t18 127.668
R512 O_REGEN_CLK.t27 O_REGEN_CLK.n20 127.668
R513 O_REGEN_CLK.t28 O_REGEN_CLK.n41 127.668
R514 O_REGEN_CLK.n40 O_REGEN_CLK.t29 127.668
R515 O_REGEN_CLK.n32 O_REGEN_CLK.t34 127.668
R516 O_REGEN_CLK.n31 O_REGEN_CLK.t33 127.668
R517 O_REGEN_CLK.n30 O_REGEN_CLK.t32 127.668
R518 O_REGEN_CLK.t31 O_REGEN_CLK.n25 127.668
R519 O_REGEN_CLK.n39 O_REGEN_CLK.t30 127.668
R520 O_REGEN_CLK.n11 O_REGEN_CLK.t21 127.668
R521 O_REGEN_CLK.n10 O_REGEN_CLK.t22 127.668
R522 O_REGEN_CLK.n9 O_REGEN_CLK.t23 127.668
R523 O_REGEN_CLK.t24 O_REGEN_CLK.n4 127.668
R524 O_REGEN_CLK.n18 O_REGEN_CLK.t25 127.668
R525 O_REGEN_CLK.n19 O_REGEN_CLK.t26 127.668
R526 O_REGEN_CLK.n84 O_REGEN_CLK.t8 113.632
R527 O_REGEN_CLK.n0 O_REGEN_CLK.t10 113.632
R528 O_REGEN_CLK.n73 O_REGEN_CLK.t12 113.632
R529 O_REGEN_CLK.n48 O_REGEN_CLK.t7 113.632
R530 O_REGEN_CLK.n52 O_REGEN_CLK.t0 113.632
R531 O_REGEN_CLK.n33 O_REGEN_CLK.t35 113.632
R532 O_REGEN_CLK.n12 O_REGEN_CLK.t20 113.632
R533 O_REGEN_CLK.n84 O_REGEN_CLK.t9 113.603
R534 O_REGEN_CLK.n0 O_REGEN_CLK.t11 113.603
R535 O_REGEN_CLK.n80 O_REGEN_CLK.t19 109.174
R536 O_REGEN_CLK.n74 O_REGEN_CLK.t13 109.174
R537 O_REGEN_CLK.n75 O_REGEN_CLK.t14 109.174
R538 O_REGEN_CLK.n76 O_REGEN_CLK.t15 109.174
R539 O_REGEN_CLK.n77 O_REGEN_CLK.t16 109.174
R540 O_REGEN_CLK.n78 O_REGEN_CLK.t17 109.174
R541 O_REGEN_CLK.n79 O_REGEN_CLK.t18 109.174
R542 O_REGEN_CLK.n55 O_REGEN_CLK.t3 109.174
R543 O_REGEN_CLK.n56 O_REGEN_CLK.t4 109.174
R544 O_REGEN_CLK.n49 O_REGEN_CLK.t6 109.174
R545 O_REGEN_CLK.n50 O_REGEN_CLK.t5 109.174
R546 O_REGEN_CLK.n54 O_REGEN_CLK.t2 109.174
R547 O_REGEN_CLK.n51 O_REGEN_CLK.t1 109.174
R548 O_REGEN_CLK.n21 O_REGEN_CLK.t27 109.174
R549 O_REGEN_CLK.n42 O_REGEN_CLK.t28 109.174
R550 O_REGEN_CLK.t29 O_REGEN_CLK.n24 109.174
R551 O_REGEN_CLK.n34 O_REGEN_CLK.t34 109.174
R552 O_REGEN_CLK.n35 O_REGEN_CLK.t33 109.174
R553 O_REGEN_CLK.n36 O_REGEN_CLK.t32 109.174
R554 O_REGEN_CLK.n37 O_REGEN_CLK.t31 109.174
R555 O_REGEN_CLK.t30 O_REGEN_CLK.n38 109.174
R556 O_REGEN_CLK.n13 O_REGEN_CLK.t21 109.174
R557 O_REGEN_CLK.n14 O_REGEN_CLK.t22 109.174
R558 O_REGEN_CLK.n15 O_REGEN_CLK.t23 109.174
R559 O_REGEN_CLK.n16 O_REGEN_CLK.t24 109.174
R560 O_REGEN_CLK.t25 O_REGEN_CLK.n17 109.174
R561 O_REGEN_CLK.t26 O_REGEN_CLK.n3 109.174
R562 O_REGEN_CLK.n60 O_REGEN_CLK.n0 27.7007
R563 O_REGEN_CLK.n85 O_REGEN_CLK.n84 22.692
R564 O_REGEN_CLK.n59 O_REGEN_CLK.n58 20.0962
R565 O_REGEN_CLK.n81 O_REGEN_CLK.n80 18.4942
R566 O_REGEN_CLK.n75 O_REGEN_CLK.n66 18.4942
R567 O_REGEN_CLK.n76 O_REGEN_CLK.n65 18.4942
R568 O_REGEN_CLK.n77 O_REGEN_CLK.n64 18.4942
R569 O_REGEN_CLK.n78 O_REGEN_CLK.n63 18.4942
R570 O_REGEN_CLK.n79 O_REGEN_CLK.n62 18.4942
R571 O_REGEN_CLK.n55 O_REGEN_CLK.n46 18.4942
R572 O_REGEN_CLK.n57 O_REGEN_CLK.n56 18.4942
R573 O_REGEN_CLK.n50 O_REGEN_CLK.n47 18.4942
R574 O_REGEN_CLK.n54 O_REGEN_CLK.n53 18.4942
R575 O_REGEN_CLK.n22 O_REGEN_CLK.n21 18.4942
R576 O_REGEN_CLK.n43 O_REGEN_CLK.n42 18.4942
R577 O_REGEN_CLK.n24 O_REGEN_CLK.n23 18.4942
R578 O_REGEN_CLK.n35 O_REGEN_CLK.n29 18.4942
R579 O_REGEN_CLK.n36 O_REGEN_CLK.n28 18.4942
R580 O_REGEN_CLK.n37 O_REGEN_CLK.n27 18.4942
R581 O_REGEN_CLK.n38 O_REGEN_CLK.n26 18.4942
R582 O_REGEN_CLK.n14 O_REGEN_CLK.n8 18.4942
R583 O_REGEN_CLK.n15 O_REGEN_CLK.n7 18.4942
R584 O_REGEN_CLK.n16 O_REGEN_CLK.n6 18.4942
R585 O_REGEN_CLK.n17 O_REGEN_CLK.n5 18.4942
R586 O_REGEN_CLK.n3 O_REGEN_CLK.n2 18.4942
R587 O_REGEN_CLK O_REGEN_CLK.n85 15.9857
R588 O_REGEN_CLK.n75 O_REGEN_CLK.n74 11.6805
R589 O_REGEN_CLK.n76 O_REGEN_CLK.n75 11.6805
R590 O_REGEN_CLK.n77 O_REGEN_CLK.n76 11.6805
R591 O_REGEN_CLK.n78 O_REGEN_CLK.n77 11.6805
R592 O_REGEN_CLK.n79 O_REGEN_CLK.n78 11.6805
R593 O_REGEN_CLK.n80 O_REGEN_CLK.n79 11.6805
R594 O_REGEN_CLK.n55 O_REGEN_CLK.n54 11.6805
R595 O_REGEN_CLK.n56 O_REGEN_CLK.n55 11.6805
R596 O_REGEN_CLK.n50 O_REGEN_CLK.n49 11.6805
R597 O_REGEN_CLK.n56 O_REGEN_CLK.n50 11.6805
R598 O_REGEN_CLK.n54 O_REGEN_CLK.n51 11.6805
R599 O_REGEN_CLK.n42 O_REGEN_CLK.n24 11.6805
R600 O_REGEN_CLK.n35 O_REGEN_CLK.n34 11.6805
R601 O_REGEN_CLK.n36 O_REGEN_CLK.n35 11.6805
R602 O_REGEN_CLK.n37 O_REGEN_CLK.n36 11.6805
R603 O_REGEN_CLK.n38 O_REGEN_CLK.n37 11.6805
R604 O_REGEN_CLK.n38 O_REGEN_CLK.n24 11.6805
R605 O_REGEN_CLK.n14 O_REGEN_CLK.n13 11.6805
R606 O_REGEN_CLK.n15 O_REGEN_CLK.n14 11.6805
R607 O_REGEN_CLK.n16 O_REGEN_CLK.n15 11.6805
R608 O_REGEN_CLK.n17 O_REGEN_CLK.n16 11.6805
R609 O_REGEN_CLK.n17 O_REGEN_CLK.n3 11.6805
R610 O_REGEN_CLK.n21 O_REGEN_CLK.n3 11.6805
R611 O_REGEN_CLK.n82 O_REGEN_CLK.n61 10.8876
R612 O_REGEN_CLK.n45 O_REGEN_CLK.n1 10.8396
R613 O_REGEN_CLK.n83 O_REGEN_CLK.n82 10.3248
R614 O_REGEN_CLK.n82 O_REGEN_CLK.n81 9.0485
R615 O_REGEN_CLK.n45 O_REGEN_CLK.n44 9.0005
R616 O_REGEN_CLK.n73 O_REGEN_CLK.n66 7.17687
R617 O_REGEN_CLK.n53 O_REGEN_CLK.n52 7.17687
R618 O_REGEN_CLK.n48 O_REGEN_CLK.n47 7.17687
R619 O_REGEN_CLK.n33 O_REGEN_CLK.n29 7.17687
R620 O_REGEN_CLK.n12 O_REGEN_CLK.n8 7.17687
R621 O_REGEN_CLK.n59 O_REGEN_CLK.n45 5.82479
R622 O_REGEN_CLK.n60 O_REGEN_CLK.n59 4.5005
R623 O_REGEN_CLK.n74 O_REGEN_CLK.n73 4.42851
R624 O_REGEN_CLK.n49 O_REGEN_CLK.n48 4.42851
R625 O_REGEN_CLK.n52 O_REGEN_CLK.n51 4.42851
R626 O_REGEN_CLK.n34 O_REGEN_CLK.n33 4.42851
R627 O_REGEN_CLK.n13 O_REGEN_CLK.n12 4.42851
R628 O_REGEN_CLK.n85 O_REGEN_CLK.n83 3.83528
R629 O_REGEN_CLK.n83 O_REGEN_CLK.n60 2.89615
R630 O_REGEN_CLK.n44 O_REGEN_CLK.n22 0.4685
R631 O_REGEN_CLK.n20 O_REGEN_CLK.n1 0.4685
R632 O_REGEN_CLK.n41 O_REGEN_CLK.n1 0.4685
R633 O_REGEN_CLK.n44 O_REGEN_CLK.n43 0.4685
R634 O_REGEN_CLK.n81 O_REGEN_CLK.n62 0.1205
R635 O_REGEN_CLK.n63 O_REGEN_CLK.n62 0.1205
R636 O_REGEN_CLK.n64 O_REGEN_CLK.n63 0.1205
R637 O_REGEN_CLK.n65 O_REGEN_CLK.n64 0.1205
R638 O_REGEN_CLK.n66 O_REGEN_CLK.n65 0.1205
R639 O_REGEN_CLK.n67 O_REGEN_CLK.n61 0.1205
R640 O_REGEN_CLK.n68 O_REGEN_CLK.n67 0.1205
R641 O_REGEN_CLK.n69 O_REGEN_CLK.n68 0.1205
R642 O_REGEN_CLK.n70 O_REGEN_CLK.n69 0.1205
R643 O_REGEN_CLK.n71 O_REGEN_CLK.n70 0.1205
R644 O_REGEN_CLK.n72 O_REGEN_CLK.n71 0.1205
R645 O_REGEN_CLK.n53 O_REGEN_CLK.n46 0.1205
R646 O_REGEN_CLK.n57 O_REGEN_CLK.n47 0.1205
R647 O_REGEN_CLK.n22 O_REGEN_CLK.n2 0.1205
R648 O_REGEN_CLK.n5 O_REGEN_CLK.n2 0.1205
R649 O_REGEN_CLK.n6 O_REGEN_CLK.n5 0.1205
R650 O_REGEN_CLK.n7 O_REGEN_CLK.n6 0.1205
R651 O_REGEN_CLK.n8 O_REGEN_CLK.n7 0.1205
R652 O_REGEN_CLK.n20 O_REGEN_CLK.n19 0.1205
R653 O_REGEN_CLK.n19 O_REGEN_CLK.n18 0.1205
R654 O_REGEN_CLK.n18 O_REGEN_CLK.n4 0.1205
R655 O_REGEN_CLK.n9 O_REGEN_CLK.n4 0.1205
R656 O_REGEN_CLK.n10 O_REGEN_CLK.n9 0.1205
R657 O_REGEN_CLK.n11 O_REGEN_CLK.n10 0.1205
R658 O_REGEN_CLK.n32 O_REGEN_CLK.n31 0.1205
R659 O_REGEN_CLK.n31 O_REGEN_CLK.n30 0.1205
R660 O_REGEN_CLK.n30 O_REGEN_CLK.n25 0.1205
R661 O_REGEN_CLK.n39 O_REGEN_CLK.n25 0.1205
R662 O_REGEN_CLK.n40 O_REGEN_CLK.n39 0.1205
R663 O_REGEN_CLK.n41 O_REGEN_CLK.n40 0.1205
R664 O_REGEN_CLK.n29 O_REGEN_CLK.n28 0.1205
R665 O_REGEN_CLK.n28 O_REGEN_CLK.n27 0.1205
R666 O_REGEN_CLK.n27 O_REGEN_CLK.n26 0.1205
R667 O_REGEN_CLK.n26 O_REGEN_CLK.n23 0.1205
R668 O_REGEN_CLK.n43 O_REGEN_CLK.n23 0.1205
R669 O_REGEN_CLK.n58 O_REGEN_CLK.n46 0.0485
R670 O_REGEN_CLK.n58 O_REGEN_CLK.n57 0.0485
R671 E_REGEN_CLK.t27 E_REGEN_CLK.n34 127.788
R672 E_REGEN_CLK.t12 E_REGEN_CLK.n11 127.788
R673 E_REGEN_CLK.n69 E_REGEN_CLK.t35 127.788
R674 E_REGEN_CLK.t19 E_REGEN_CLK.n20 127.668
R675 E_REGEN_CLK.n34 E_REGEN_CLK.t26 127.668
R676 E_REGEN_CLK.n33 E_REGEN_CLK.t25 127.668
R677 E_REGEN_CLK.n32 E_REGEN_CLK.t24 127.668
R678 E_REGEN_CLK.n31 E_REGEN_CLK.t23 127.668
R679 E_REGEN_CLK.n30 E_REGEN_CLK.t22 127.668
R680 E_REGEN_CLK.n29 E_REGEN_CLK.t21 127.668
R681 E_REGEN_CLK.n28 E_REGEN_CLK.t20 127.668
R682 E_REGEN_CLK.n11 E_REGEN_CLK.t13 127.668
R683 E_REGEN_CLK.n10 E_REGEN_CLK.t14 127.668
R684 E_REGEN_CLK.n9 E_REGEN_CLK.t15 127.668
R685 E_REGEN_CLK.t16 E_REGEN_CLK.n4 127.668
R686 E_REGEN_CLK.n18 E_REGEN_CLK.t17 127.668
R687 E_REGEN_CLK.n19 E_REGEN_CLK.t18 127.668
R688 E_REGEN_CLK.t28 E_REGEN_CLK.n61 127.668
R689 E_REGEN_CLK.t29 E_REGEN_CLK.n78 127.668
R690 E_REGEN_CLK.n77 E_REGEN_CLK.t30 127.668
R691 E_REGEN_CLK.n76 E_REGEN_CLK.t31 127.668
R692 E_REGEN_CLK.t32 E_REGEN_CLK.n64 127.668
R693 E_REGEN_CLK.t33 E_REGEN_CLK.n70 127.668
R694 E_REGEN_CLK.n69 E_REGEN_CLK.t34 127.668
R695 E_REGEN_CLK.n0 E_REGEN_CLK.t9 113.632
R696 E_REGEN_CLK.n84 E_REGEN_CLK.t11 113.632
R697 E_REGEN_CLK.n48 E_REGEN_CLK.t7 113.632
R698 E_REGEN_CLK.n52 E_REGEN_CLK.t0 113.632
R699 E_REGEN_CLK.n35 E_REGEN_CLK.t27 113.632
R700 E_REGEN_CLK.n12 E_REGEN_CLK.t12 113.632
R701 E_REGEN_CLK.t35 E_REGEN_CLK.n67 113.632
R702 E_REGEN_CLK.n0 E_REGEN_CLK.t8 113.603
R703 E_REGEN_CLK.n84 E_REGEN_CLK.t10 113.603
R704 E_REGEN_CLK.n55 E_REGEN_CLK.t3 109.174
R705 E_REGEN_CLK.n56 E_REGEN_CLK.t4 109.174
R706 E_REGEN_CLK.n49 E_REGEN_CLK.t6 109.174
R707 E_REGEN_CLK.n50 E_REGEN_CLK.t5 109.174
R708 E_REGEN_CLK.n54 E_REGEN_CLK.t2 109.174
R709 E_REGEN_CLK.n51 E_REGEN_CLK.t1 109.174
R710 E_REGEN_CLK.n21 E_REGEN_CLK.t19 109.174
R711 E_REGEN_CLK.t26 E_REGEN_CLK.n27 109.174
R712 E_REGEN_CLK.n37 E_REGEN_CLK.t25 109.174
R713 E_REGEN_CLK.n38 E_REGEN_CLK.t24 109.174
R714 E_REGEN_CLK.n39 E_REGEN_CLK.t23 109.174
R715 E_REGEN_CLK.n40 E_REGEN_CLK.t22 109.174
R716 E_REGEN_CLK.n41 E_REGEN_CLK.t21 109.174
R717 E_REGEN_CLK.n42 E_REGEN_CLK.t20 109.174
R718 E_REGEN_CLK.n13 E_REGEN_CLK.t13 109.174
R719 E_REGEN_CLK.n14 E_REGEN_CLK.t14 109.174
R720 E_REGEN_CLK.n15 E_REGEN_CLK.t15 109.174
R721 E_REGEN_CLK.n16 E_REGEN_CLK.t16 109.174
R722 E_REGEN_CLK.t17 E_REGEN_CLK.n17 109.174
R723 E_REGEN_CLK.t18 E_REGEN_CLK.n3 109.174
R724 E_REGEN_CLK.n80 E_REGEN_CLK.t28 109.174
R725 E_REGEN_CLK.n79 E_REGEN_CLK.t29 109.174
R726 E_REGEN_CLK.t30 E_REGEN_CLK.n63 109.174
R727 E_REGEN_CLK.t31 E_REGEN_CLK.n75 109.174
R728 E_REGEN_CLK.n65 E_REGEN_CLK.t32 109.174
R729 E_REGEN_CLK.n71 E_REGEN_CLK.t33 109.174
R730 E_REGEN_CLK.t34 E_REGEN_CLK.n68 109.174
R731 E_REGEN_CLK.n60 E_REGEN_CLK.n0 27.7007
R732 E_REGEN_CLK.n85 E_REGEN_CLK.n84 22.692
R733 E_REGEN_CLK.n59 E_REGEN_CLK.n58 20.0962
R734 E_REGEN_CLK.n55 E_REGEN_CLK.n46 18.4942
R735 E_REGEN_CLK.n57 E_REGEN_CLK.n56 18.4942
R736 E_REGEN_CLK.n50 E_REGEN_CLK.n47 18.4942
R737 E_REGEN_CLK.n54 E_REGEN_CLK.n53 18.4942
R738 E_REGEN_CLK.n22 E_REGEN_CLK.n21 18.4942
R739 E_REGEN_CLK.n37 E_REGEN_CLK.n36 18.4942
R740 E_REGEN_CLK.n38 E_REGEN_CLK.n26 18.4942
R741 E_REGEN_CLK.n39 E_REGEN_CLK.n25 18.4942
R742 E_REGEN_CLK.n40 E_REGEN_CLK.n24 18.4942
R743 E_REGEN_CLK.n41 E_REGEN_CLK.n23 18.4942
R744 E_REGEN_CLK.n43 E_REGEN_CLK.n42 18.4942
R745 E_REGEN_CLK.n14 E_REGEN_CLK.n8 18.4942
R746 E_REGEN_CLK.n15 E_REGEN_CLK.n7 18.4942
R747 E_REGEN_CLK.n16 E_REGEN_CLK.n6 18.4942
R748 E_REGEN_CLK.n17 E_REGEN_CLK.n5 18.4942
R749 E_REGEN_CLK.n3 E_REGEN_CLK.n2 18.4942
R750 E_REGEN_CLK.n81 E_REGEN_CLK.n80 18.4942
R751 E_REGEN_CLK.n79 E_REGEN_CLK.n62 18.4942
R752 E_REGEN_CLK.n66 E_REGEN_CLK.n63 18.4942
R753 E_REGEN_CLK.n75 E_REGEN_CLK.n74 18.4942
R754 E_REGEN_CLK.n73 E_REGEN_CLK.n65 18.4942
R755 E_REGEN_CLK.n72 E_REGEN_CLK.n71 18.4942
R756 E_REGEN_CLK E_REGEN_CLK.n85 15.9857
R757 E_REGEN_CLK.n55 E_REGEN_CLK.n54 11.6805
R758 E_REGEN_CLK.n56 E_REGEN_CLK.n55 11.6805
R759 E_REGEN_CLK.n50 E_REGEN_CLK.n49 11.6805
R760 E_REGEN_CLK.n56 E_REGEN_CLK.n50 11.6805
R761 E_REGEN_CLK.n54 E_REGEN_CLK.n51 11.6805
R762 E_REGEN_CLK.n38 E_REGEN_CLK.n37 11.6805
R763 E_REGEN_CLK.n37 E_REGEN_CLK.n27 11.6805
R764 E_REGEN_CLK.n39 E_REGEN_CLK.n38 11.6805
R765 E_REGEN_CLK.n40 E_REGEN_CLK.n39 11.6805
R766 E_REGEN_CLK.n41 E_REGEN_CLK.n40 11.6805
R767 E_REGEN_CLK.n42 E_REGEN_CLK.n41 11.6805
R768 E_REGEN_CLK.n14 E_REGEN_CLK.n13 11.6805
R769 E_REGEN_CLK.n15 E_REGEN_CLK.n14 11.6805
R770 E_REGEN_CLK.n16 E_REGEN_CLK.n15 11.6805
R771 E_REGEN_CLK.n17 E_REGEN_CLK.n16 11.6805
R772 E_REGEN_CLK.n17 E_REGEN_CLK.n3 11.6805
R773 E_REGEN_CLK.n21 E_REGEN_CLK.n3 11.6805
R774 E_REGEN_CLK.n80 E_REGEN_CLK.n79 11.6805
R775 E_REGEN_CLK.n79 E_REGEN_CLK.n63 11.6805
R776 E_REGEN_CLK.n75 E_REGEN_CLK.n63 11.6805
R777 E_REGEN_CLK.n75 E_REGEN_CLK.n65 11.6805
R778 E_REGEN_CLK.n71 E_REGEN_CLK.n65 11.6805
R779 E_REGEN_CLK.n71 E_REGEN_CLK.n68 11.6805
R780 E_REGEN_CLK.n82 E_REGEN_CLK.n61 10.8876
R781 E_REGEN_CLK.n45 E_REGEN_CLK.n1 10.8396
R782 E_REGEN_CLK.n83 E_REGEN_CLK.n82 10.3248
R783 E_REGEN_CLK.n82 E_REGEN_CLK.n81 9.0485
R784 E_REGEN_CLK.n45 E_REGEN_CLK.n44 9.0005
R785 E_REGEN_CLK.n53 E_REGEN_CLK.n52 7.17687
R786 E_REGEN_CLK.n48 E_REGEN_CLK.n47 7.17687
R787 E_REGEN_CLK.n36 E_REGEN_CLK.n35 7.17687
R788 E_REGEN_CLK.n12 E_REGEN_CLK.n8 7.17687
R789 E_REGEN_CLK.n72 E_REGEN_CLK.n67 7.17687
R790 E_REGEN_CLK.n59 E_REGEN_CLK.n45 5.82479
R791 E_REGEN_CLK.n60 E_REGEN_CLK.n59 4.5005
R792 E_REGEN_CLK.n49 E_REGEN_CLK.n48 4.42851
R793 E_REGEN_CLK.n52 E_REGEN_CLK.n51 4.42851
R794 E_REGEN_CLK.n35 E_REGEN_CLK.n27 4.42851
R795 E_REGEN_CLK.n13 E_REGEN_CLK.n12 4.42851
R796 E_REGEN_CLK.n68 E_REGEN_CLK.n67 4.42851
R797 E_REGEN_CLK.n85 E_REGEN_CLK.n83 3.83528
R798 E_REGEN_CLK.n83 E_REGEN_CLK.n60 2.89615
R799 E_REGEN_CLK.n44 E_REGEN_CLK.n22 0.4685
R800 E_REGEN_CLK.n20 E_REGEN_CLK.n1 0.4685
R801 E_REGEN_CLK.n28 E_REGEN_CLK.n1 0.4685
R802 E_REGEN_CLK.n44 E_REGEN_CLK.n43 0.4685
R803 E_REGEN_CLK.n53 E_REGEN_CLK.n46 0.1205
R804 E_REGEN_CLK.n57 E_REGEN_CLK.n47 0.1205
R805 E_REGEN_CLK.n22 E_REGEN_CLK.n2 0.1205
R806 E_REGEN_CLK.n5 E_REGEN_CLK.n2 0.1205
R807 E_REGEN_CLK.n6 E_REGEN_CLK.n5 0.1205
R808 E_REGEN_CLK.n7 E_REGEN_CLK.n6 0.1205
R809 E_REGEN_CLK.n8 E_REGEN_CLK.n7 0.1205
R810 E_REGEN_CLK.n20 E_REGEN_CLK.n19 0.1205
R811 E_REGEN_CLK.n19 E_REGEN_CLK.n18 0.1205
R812 E_REGEN_CLK.n18 E_REGEN_CLK.n4 0.1205
R813 E_REGEN_CLK.n9 E_REGEN_CLK.n4 0.1205
R814 E_REGEN_CLK.n10 E_REGEN_CLK.n9 0.1205
R815 E_REGEN_CLK.n11 E_REGEN_CLK.n10 0.1205
R816 E_REGEN_CLK.n34 E_REGEN_CLK.n33 0.1205
R817 E_REGEN_CLK.n33 E_REGEN_CLK.n32 0.1205
R818 E_REGEN_CLK.n32 E_REGEN_CLK.n31 0.1205
R819 E_REGEN_CLK.n31 E_REGEN_CLK.n30 0.1205
R820 E_REGEN_CLK.n30 E_REGEN_CLK.n29 0.1205
R821 E_REGEN_CLK.n29 E_REGEN_CLK.n28 0.1205
R822 E_REGEN_CLK.n36 E_REGEN_CLK.n26 0.1205
R823 E_REGEN_CLK.n26 E_REGEN_CLK.n25 0.1205
R824 E_REGEN_CLK.n25 E_REGEN_CLK.n24 0.1205
R825 E_REGEN_CLK.n24 E_REGEN_CLK.n23 0.1205
R826 E_REGEN_CLK.n43 E_REGEN_CLK.n23 0.1205
R827 E_REGEN_CLK.n73 E_REGEN_CLK.n72 0.1205
R828 E_REGEN_CLK.n74 E_REGEN_CLK.n73 0.1205
R829 E_REGEN_CLK.n74 E_REGEN_CLK.n66 0.1205
R830 E_REGEN_CLK.n66 E_REGEN_CLK.n62 0.1205
R831 E_REGEN_CLK.n81 E_REGEN_CLK.n62 0.1205
R832 E_REGEN_CLK.n70 E_REGEN_CLK.n69 0.1205
R833 E_REGEN_CLK.n70 E_REGEN_CLK.n64 0.1205
R834 E_REGEN_CLK.n76 E_REGEN_CLK.n64 0.1205
R835 E_REGEN_CLK.n77 E_REGEN_CLK.n76 0.1205
R836 E_REGEN_CLK.n78 E_REGEN_CLK.n77 0.1205
R837 E_REGEN_CLK.n78 E_REGEN_CLK.n61 0.1205
R838 E_REGEN_CLK.n58 E_REGEN_CLK.n46 0.0485
R839 E_REGEN_CLK.n58 E_REGEN_CLK.n57 0.0485
R840 O_REGEN_CLKB.t7 O_REGEN_CLKB.n32 127.788
R841 O_REGEN_CLKB.n16 O_REGEN_CLKB.t15 127.788
R842 O_REGEN_CLKB.t8 O_REGEN_CLKB.n7 127.788
R843 O_REGEN_CLKB.t0 O_REGEN_CLKB.n21 127.737
R844 O_REGEN_CLKB.n32 O_REGEN_CLKB.t6 127.668
R845 O_REGEN_CLKB.n31 O_REGEN_CLKB.t5 127.668
R846 O_REGEN_CLKB.n30 O_REGEN_CLKB.t4 127.668
R847 O_REGEN_CLKB.n29 O_REGEN_CLKB.t3 127.668
R848 O_REGEN_CLKB.n28 O_REGEN_CLKB.t2 127.668
R849 O_REGEN_CLKB.n27 O_REGEN_CLKB.t1 127.668
R850 O_REGEN_CLKB.t13 O_REGEN_CLKB.n14 127.668
R851 O_REGEN_CLKB.t14 O_REGEN_CLKB.n16 127.668
R852 O_REGEN_CLKB.n7 O_REGEN_CLKB.t9 127.668
R853 O_REGEN_CLKB.t10 O_REGEN_CLKB.n3 127.668
R854 O_REGEN_CLKB.n12 O_REGEN_CLKB.t11 127.668
R855 O_REGEN_CLKB.n13 O_REGEN_CLKB.t12 127.668
R856 O_REGEN_CLKB.n33 O_REGEN_CLKB.t7 113.632
R857 O_REGEN_CLKB.n18 O_REGEN_CLKB.t15 113.632
R858 O_REGEN_CLKB.n8 O_REGEN_CLKB.t8 113.632
R859 O_REGEN_CLKB.n22 O_REGEN_CLKB.t0 109.174
R860 O_REGEN_CLKB.t6 O_REGEN_CLKB.n26 109.174
R861 O_REGEN_CLKB.n35 O_REGEN_CLKB.t5 109.174
R862 O_REGEN_CLKB.n36 O_REGEN_CLKB.t4 109.174
R863 O_REGEN_CLKB.n37 O_REGEN_CLKB.t3 109.174
R864 O_REGEN_CLKB.n38 O_REGEN_CLKB.t2 109.174
R865 O_REGEN_CLKB.n39 O_REGEN_CLKB.t1 109.174
R866 O_REGEN_CLKB.n15 O_REGEN_CLKB.t13 109.174
R867 O_REGEN_CLKB.n17 O_REGEN_CLKB.t14 109.174
R868 O_REGEN_CLKB.n9 O_REGEN_CLKB.t9 109.174
R869 O_REGEN_CLKB.n10 O_REGEN_CLKB.t10 109.174
R870 O_REGEN_CLKB.t11 O_REGEN_CLKB.n11 109.174
R871 O_REGEN_CLKB.t12 O_REGEN_CLKB.n2 109.174
R872 O_REGEN_CLKB.n43 O_REGEN_CLKB.n20 24.2273
R873 O_REGEN_CLKB.n41 O_REGEN_CLKB.n22 18.5636
R874 O_REGEN_CLKB.n35 O_REGEN_CLKB.n34 18.4942
R875 O_REGEN_CLKB.n36 O_REGEN_CLKB.n25 18.4942
R876 O_REGEN_CLKB.n37 O_REGEN_CLKB.n24 18.4942
R877 O_REGEN_CLKB.n38 O_REGEN_CLKB.n23 18.4942
R878 O_REGEN_CLKB.n40 O_REGEN_CLKB.n39 18.4942
R879 O_REGEN_CLKB.n15 O_REGEN_CLKB.n1 18.4942
R880 O_REGEN_CLKB.n10 O_REGEN_CLKB.n6 18.4942
R881 O_REGEN_CLKB.n11 O_REGEN_CLKB.n5 18.4942
R882 O_REGEN_CLKB.n4 O_REGEN_CLKB.n2 18.4942
R883 O_REGEN_CLKB O_REGEN_CLKB.n43 16.7683
R884 O_REGEN_CLKB.n43 O_REGEN_CLKB.n42 14.0534
R885 O_REGEN_CLKB.n36 O_REGEN_CLKB.n35 11.6805
R886 O_REGEN_CLKB.n35 O_REGEN_CLKB.n26 11.6805
R887 O_REGEN_CLKB.n37 O_REGEN_CLKB.n36 11.6805
R888 O_REGEN_CLKB.n38 O_REGEN_CLKB.n37 11.6805
R889 O_REGEN_CLKB.n39 O_REGEN_CLKB.n38 11.6805
R890 O_REGEN_CLKB.n39 O_REGEN_CLKB.n22 11.6805
R891 O_REGEN_CLKB.n17 O_REGEN_CLKB.n15 11.6805
R892 O_REGEN_CLKB.n10 O_REGEN_CLKB.n9 11.6805
R893 O_REGEN_CLKB.n11 O_REGEN_CLKB.n10 11.6805
R894 O_REGEN_CLKB.n11 O_REGEN_CLKB.n2 11.6805
R895 O_REGEN_CLKB.n15 O_REGEN_CLKB.n2 11.6805
R896 O_REGEN_CLKB.n42 O_REGEN_CLKB.n21 10.8396
R897 O_REGEN_CLKB.n20 O_REGEN_CLKB.n0 10.8396
R898 O_REGEN_CLKB.n42 O_REGEN_CLKB.n41 9.0005
R899 O_REGEN_CLKB.n20 O_REGEN_CLKB.n19 9.0005
R900 O_REGEN_CLKB.n34 O_REGEN_CLKB.n33 7.17687
R901 O_REGEN_CLKB.n8 O_REGEN_CLKB.n6 7.17687
R902 O_REGEN_CLKB.n19 O_REGEN_CLKB.n18 7.10487
R903 O_REGEN_CLKB.n33 O_REGEN_CLKB.n26 4.42851
R904 O_REGEN_CLKB.n18 O_REGEN_CLKB.n17 4.42851
R905 O_REGEN_CLKB.n9 O_REGEN_CLKB.n8 4.42851
R906 O_REGEN_CLKB.n32 O_REGEN_CLKB.n31 0.1205
R907 O_REGEN_CLKB.n31 O_REGEN_CLKB.n30 0.1205
R908 O_REGEN_CLKB.n30 O_REGEN_CLKB.n29 0.1205
R909 O_REGEN_CLKB.n29 O_REGEN_CLKB.n28 0.1205
R910 O_REGEN_CLKB.n28 O_REGEN_CLKB.n27 0.1205
R911 O_REGEN_CLKB.n34 O_REGEN_CLKB.n25 0.1205
R912 O_REGEN_CLKB.n25 O_REGEN_CLKB.n24 0.1205
R913 O_REGEN_CLKB.n24 O_REGEN_CLKB.n23 0.1205
R914 O_REGEN_CLKB.n40 O_REGEN_CLKB.n23 0.1205
R915 O_REGEN_CLKB.n4 O_REGEN_CLKB.n1 0.1205
R916 O_REGEN_CLKB.n5 O_REGEN_CLKB.n4 0.1205
R917 O_REGEN_CLKB.n6 O_REGEN_CLKB.n5 0.1205
R918 O_REGEN_CLKB.n14 O_REGEN_CLKB.n13 0.1205
R919 O_REGEN_CLKB.n13 O_REGEN_CLKB.n12 0.1205
R920 O_REGEN_CLKB.n12 O_REGEN_CLKB.n3 0.1205
R921 O_REGEN_CLKB.n7 O_REGEN_CLKB.n3 0.1205
R922 O_REGEN_CLKB.n27 O_REGEN_CLKB.n21 0.0485
R923 O_REGEN_CLKB.n41 O_REGEN_CLKB.n40 0.0485
R924 O_REGEN_CLKB.n19 O_REGEN_CLKB.n1 0.0485
R925 O_REGEN_CLKB.n14 O_REGEN_CLKB.n0 0.0485
R926 O_REGEN_CLKB.n16 O_REGEN_CLKB.n0 0.0485
R927 E_REGEN_CLKB.t7 E_REGEN_CLKB.n11 127.788
R928 E_REGEN_CLKB.n3 E_REGEN_CLKB.t0 127.788
R929 E_REGEN_CLKB.t8 E_REGEN_CLKB.n30 127.788
R930 E_REGEN_CLKB.t15 E_REGEN_CLKB.n21 127.737
R931 E_REGEN_CLKB.t1 E_REGEN_CLKB.n3 127.668
R932 E_REGEN_CLKB.n11 E_REGEN_CLKB.t6 127.668
R933 E_REGEN_CLKB.n10 E_REGEN_CLKB.t5 127.668
R934 E_REGEN_CLKB.n9 E_REGEN_CLKB.t4 127.668
R935 E_REGEN_CLKB.n8 E_REGEN_CLKB.t3 127.668
R936 E_REGEN_CLKB.n7 E_REGEN_CLKB.t2 127.668
R937 E_REGEN_CLKB.t14 E_REGEN_CLKB.n38 127.668
R938 E_REGEN_CLKB.n30 E_REGEN_CLKB.t9 127.668
R939 E_REGEN_CLKB.n29 E_REGEN_CLKB.t10 127.668
R940 E_REGEN_CLKB.t11 E_REGEN_CLKB.n24 127.668
R941 E_REGEN_CLKB.n36 E_REGEN_CLKB.t12 127.668
R942 E_REGEN_CLKB.n37 E_REGEN_CLKB.t13 127.668
R943 E_REGEN_CLKB.n12 E_REGEN_CLKB.t7 113.632
R944 E_REGEN_CLKB.t0 E_REGEN_CLKB.n1 113.632
R945 E_REGEN_CLKB.n31 E_REGEN_CLKB.t8 113.632
R946 E_REGEN_CLKB.n4 E_REGEN_CLKB.t1 109.174
R947 E_REGEN_CLKB.t6 E_REGEN_CLKB.n6 109.174
R948 E_REGEN_CLKB.n14 E_REGEN_CLKB.t5 109.174
R949 E_REGEN_CLKB.n15 E_REGEN_CLKB.t4 109.174
R950 E_REGEN_CLKB.n16 E_REGEN_CLKB.t3 109.174
R951 E_REGEN_CLKB.n17 E_REGEN_CLKB.t2 109.174
R952 E_REGEN_CLKB.n39 E_REGEN_CLKB.t14 109.174
R953 E_REGEN_CLKB.n40 E_REGEN_CLKB.t15 109.174
R954 E_REGEN_CLKB.n32 E_REGEN_CLKB.t9 109.174
R955 E_REGEN_CLKB.n33 E_REGEN_CLKB.t10 109.174
R956 E_REGEN_CLKB.n34 E_REGEN_CLKB.t11 109.174
R957 E_REGEN_CLKB.t12 E_REGEN_CLKB.n35 109.174
R958 E_REGEN_CLKB.t13 E_REGEN_CLKB.n23 109.174
R959 E_REGEN_CLKB.n43 E_REGEN_CLKB.n20 24.2273
R960 E_REGEN_CLKB.n41 E_REGEN_CLKB.n40 18.5636
R961 E_REGEN_CLKB.n14 E_REGEN_CLKB.n13 18.4942
R962 E_REGEN_CLKB.n15 E_REGEN_CLKB.n5 18.4942
R963 E_REGEN_CLKB.n16 E_REGEN_CLKB.n2 18.4942
R964 E_REGEN_CLKB.n18 E_REGEN_CLKB.n17 18.4942
R965 E_REGEN_CLKB.n39 E_REGEN_CLKB.n22 18.4942
R966 E_REGEN_CLKB.n33 E_REGEN_CLKB.n28 18.4942
R967 E_REGEN_CLKB.n34 E_REGEN_CLKB.n27 18.4942
R968 E_REGEN_CLKB.n35 E_REGEN_CLKB.n26 18.4942
R969 E_REGEN_CLKB.n25 E_REGEN_CLKB.n23 18.4942
R970 E_REGEN_CLKB E_REGEN_CLKB.n43 16.7683
R971 E_REGEN_CLKB.n43 E_REGEN_CLKB.n42 14.0534
R972 E_REGEN_CLKB.n15 E_REGEN_CLKB.n14 11.6805
R973 E_REGEN_CLKB.n14 E_REGEN_CLKB.n6 11.6805
R974 E_REGEN_CLKB.n16 E_REGEN_CLKB.n15 11.6805
R975 E_REGEN_CLKB.n17 E_REGEN_CLKB.n16 11.6805
R976 E_REGEN_CLKB.n17 E_REGEN_CLKB.n4 11.6805
R977 E_REGEN_CLKB.n40 E_REGEN_CLKB.n39 11.6805
R978 E_REGEN_CLKB.n33 E_REGEN_CLKB.n32 11.6805
R979 E_REGEN_CLKB.n34 E_REGEN_CLKB.n33 11.6805
R980 E_REGEN_CLKB.n35 E_REGEN_CLKB.n34 11.6805
R981 E_REGEN_CLKB.n35 E_REGEN_CLKB.n23 11.6805
R982 E_REGEN_CLKB.n39 E_REGEN_CLKB.n23 11.6805
R983 E_REGEN_CLKB.n20 E_REGEN_CLKB.n0 10.8396
R984 E_REGEN_CLKB.n42 E_REGEN_CLKB.n21 10.8396
R985 E_REGEN_CLKB.n20 E_REGEN_CLKB.n19 9.0005
R986 E_REGEN_CLKB.n42 E_REGEN_CLKB.n41 9.0005
R987 E_REGEN_CLKB.n13 E_REGEN_CLKB.n12 7.17687
R988 E_REGEN_CLKB.n31 E_REGEN_CLKB.n28 7.17687
R989 E_REGEN_CLKB.n19 E_REGEN_CLKB.n1 7.10487
R990 E_REGEN_CLKB.n4 E_REGEN_CLKB.n1 4.42851
R991 E_REGEN_CLKB.n12 E_REGEN_CLKB.n6 4.42851
R992 E_REGEN_CLKB.n32 E_REGEN_CLKB.n31 4.42851
R993 E_REGEN_CLKB.n11 E_REGEN_CLKB.n10 0.1205
R994 E_REGEN_CLKB.n10 E_REGEN_CLKB.n9 0.1205
R995 E_REGEN_CLKB.n9 E_REGEN_CLKB.n8 0.1205
R996 E_REGEN_CLKB.n8 E_REGEN_CLKB.n7 0.1205
R997 E_REGEN_CLKB.n13 E_REGEN_CLKB.n5 0.1205
R998 E_REGEN_CLKB.n5 E_REGEN_CLKB.n2 0.1205
R999 E_REGEN_CLKB.n18 E_REGEN_CLKB.n2 0.1205
R1000 E_REGEN_CLKB.n25 E_REGEN_CLKB.n22 0.1205
R1001 E_REGEN_CLKB.n26 E_REGEN_CLKB.n25 0.1205
R1002 E_REGEN_CLKB.n27 E_REGEN_CLKB.n26 0.1205
R1003 E_REGEN_CLKB.n28 E_REGEN_CLKB.n27 0.1205
R1004 E_REGEN_CLKB.n38 E_REGEN_CLKB.n37 0.1205
R1005 E_REGEN_CLKB.n37 E_REGEN_CLKB.n36 0.1205
R1006 E_REGEN_CLKB.n36 E_REGEN_CLKB.n24 0.1205
R1007 E_REGEN_CLKB.n29 E_REGEN_CLKB.n24 0.1205
R1008 E_REGEN_CLKB.n30 E_REGEN_CLKB.n29 0.1205
R1009 E_REGEN_CLKB.n3 E_REGEN_CLKB.n0 0.0485
R1010 E_REGEN_CLKB.n7 E_REGEN_CLKB.n0 0.0485
R1011 E_REGEN_CLKB.n19 E_REGEN_CLKB.n18 0.0485
R1012 E_REGEN_CLKB.n41 E_REGEN_CLKB.n22 0.0485
R1013 E_REGEN_CLKB.n38 E_REGEN_CLKB.n21 0.0485
R1014 VDD.t396 VDD.t395 2823.53
R1015 VDD.t398 VDD.t397 2823.53
R1016 VDD.t397 VDD.t396 1411.76
R1017 VDD.n174 VDD.t90 923.077
R1018 VDD.n175 VDD.t314 923.077
R1019 VDD.n179 VDD.t308 923.077
R1020 VDD.n180 VDD.t78 923.077
R1021 VDD.n184 VDD.t296 923.077
R1022 VDD.n185 VDD.t111 923.077
R1023 VDD.t317 VDD.t92 640.625
R1024 VDD.t311 VDD.t316 640.625
R1025 VDD.t81 VDD.t310 640.625
R1026 VDD.t299 VDD.t80 640.625
R1027 VDD.t114 VDD.t298 640.625
R1028 VDD.t3 VDD.t113 640.625
R1029 VDD.n172 VDD.t90 483.238
R1030 VDD.t314 VDD.n174 461.538
R1031 VDD.n175 VDD.t308 461.538
R1032 VDD.t78 VDD.n179 461.538
R1033 VDD.n180 VDD.t296 461.538
R1034 VDD.t111 VDD.n184 461.538
R1035 VDD.n185 VDD.t0 461.538
R1036 VDD.n369 VDD.t398 407.682
R1037 VDD.n188 VDD.t2 313.94
R1038 VDD.n50 VDD.n49 166.667
R1039 VDD.n50 VDD.n35 166.667
R1040 VDD.n67 VDD.n8 166.667
R1041 VDD.n73 VDD.n8 166.667
R1042 VDD.n256 VDD.n255 166.667
R1043 VDD.n256 VDD.n199 166.667
R1044 VDD.n229 VDD.n228 166.667
R1045 VDD.n228 VDD.n212 166.667
R1046 VDD.n49 VDD.t199 143.333
R1047 VDD.t109 VDD.n73 143.333
R1048 VDD.n255 VDD.t125 143.333
R1049 VDD.t117 VDD.n212 143.333
R1050 VDD.n43 VDD.n42 106.3
R1051 VDD.n6 VDD.n4 106.3
R1052 VDD.n266 VDD.n265 106.3
R1053 VDD.n219 VDD.n218 106.3
R1054 VDD.n36 VDD.t163 93.3338
R1055 VDD.n66 VDD.t175 93.3338
R1056 VDD.n252 VDD.t218 93.3338
R1057 VDD.n230 VDD.t258 93.3338
R1058 VDD.n48 VDD.t320 86.6672
R1059 VDD.t102 VDD.n74 86.6672
R1060 VDD.t178 VDD.n264 86.6672
R1061 VDD.n220 VDD.t332 86.6672
R1062 VDD.n43 VDD.n39 70.0005
R1063 VDD.n47 VDD.n39 70.0005
R1064 VDD.n47 VDD.n34 70.0005
R1065 VDD.n51 VDD.n34 70.0005
R1066 VDD.n51 VDD.n28 70.0005
R1067 VDD.n55 VDD.n28 70.0005
R1068 VDD.n55 VDD.n26 70.0005
R1069 VDD.n58 VDD.n26 70.0005
R1070 VDD.n58 VDD.n18 70.0005
R1071 VDD.n62 VDD.n18 70.0005
R1072 VDD.n62 VDD.n17 70.0005
R1073 VDD.n17 VDD.n14 70.0005
R1074 VDD.n68 VDD.n14 70.0005
R1075 VDD.n68 VDD.n9 70.0005
R1076 VDD.n72 VDD.n9 70.0005
R1077 VDD.n72 VDD.n5 70.0005
R1078 VDD.n75 VDD.n5 70.0005
R1079 VDD.n75 VDD.n4 70.0005
R1080 VDD.n266 VDD.n193 70.0005
R1081 VDD.n263 VDD.n193 70.0005
R1082 VDD.n263 VDD.n194 70.0005
R1083 VDD.n257 VDD.n194 70.0005
R1084 VDD.n257 VDD.n198 70.0005
R1085 VDD.n250 VDD.n198 70.0005
R1086 VDD.n250 VDD.n201 70.0005
R1087 VDD.n244 VDD.n201 70.0005
R1088 VDD.n244 VDD.n205 70.0005
R1089 VDD.n241 VDD.n205 70.0005
R1090 VDD.n241 VDD.n206 70.0005
R1091 VDD.n235 VDD.n206 70.0005
R1092 VDD.n235 VDD.n210 70.0005
R1093 VDD.n227 VDD.n210 70.0005
R1094 VDD.n227 VDD.n213 70.0005
R1095 VDD.n221 VDD.n213 70.0005
R1096 VDD.n221 VDD.n217 70.0005
R1097 VDD.n218 VDD.n217 70.0005
R1098 VDD.n36 VDD.n35 66.6672
R1099 VDD.n67 VDD.n66 66.6672
R1100 VDD.n252 VDD.n199 66.6672
R1101 VDD.n230 VDD.n229 66.6672
R1102 VDD.t92 VDD.t93 62.5005
R1103 VDD.t316 VDD.t317 62.5005
R1104 VDD.t310 VDD.t311 62.5005
R1105 VDD.t80 VDD.t81 62.5005
R1106 VDD.t298 VDD.t299 62.5005
R1107 VDD.t113 VDD.t114 62.5005
R1108 VDD.t2 VDD.t3 62.5005
R1109 VDD.n42 VDD.t107 53.3338
R1110 VDD.t143 VDD.t289 53.3338
R1111 VDD.t289 VDD.t145 53.3338
R1112 VDD.t152 VDD.t287 53.3338
R1113 VDD.t287 VDD.t153 53.3338
R1114 VDD.t76 VDD.n6 53.3338
R1115 VDD.n265 VDD.t367 53.3338
R1116 VDD.t228 VDD.t285 53.3338
R1117 VDD.t285 VDD.t234 53.3338
R1118 VDD.t239 VDD.t283 53.3338
R1119 VDD.t283 VDD.t240 53.3338
R1120 VDD.t346 VDD.n219 53.3338
R1121 VDD.n362 VDD.t184 25.1121
R1122 VDD.n364 VDD.t292 24.7565
R1123 VDD.n368 VDD.t295 24.7565
R1124 VDD.n365 VDD.t312 24.7565
R1125 VDD.n158 VDD.n157 24.4328
R1126 VDD.n104 VDD.n103 24.4328
R1127 VDD.n281 VDD.n280 24.4328
R1128 VDD.n348 VDD.n347 24.4328
R1129 VDD.n80 VDD.n79 22.1797
R1130 VDD.n95 VDD.n94 22.1797
R1131 VDD.n283 VDD.n282 22.1797
R1132 VDD.n270 VDD.n269 22.1797
R1133 VDD.n359 VDD.t262 22.1461
R1134 VDD.n370 VDD.t95 21.9006
R1135 VDD.n371 VDD.t94 21.9006
R1136 VDD.n186 VDD.n185 21.6005
R1137 VDD.n184 VDD.n183 21.6005
R1138 VDD.n181 VDD.n180 21.6005
R1139 VDD.n179 VDD.n178 21.6005
R1140 VDD.n176 VDD.n175 21.6005
R1141 VDD.n174 VDD.n173 21.6005
R1142 VDD.n370 VDD.t291 21.545
R1143 VDD.n371 VDD.t282 21.545
R1144 VDD.n367 VDD.t104 21.4505
R1145 VDD.n366 VDD.t177 21.4505
R1146 VDD.n359 VDD.t281 21.435
R1147 VDD.n361 VDD.t293 21.435
R1148 VDD.n360 VDD.t261 21.435
R1149 VDD.n363 VDD.t399 21.3935
R1150 VDD.n362 VDD.t313 21.3935
R1151 VDD.n107 VDD.n105 19.4916
R1152 VDD.n346 VDD.n345 19.4916
R1153 VDD.n156 VDD.n155 19.4916
R1154 VDD.n286 VDD.n284 19.4916
R1155 VDD.n167 VDD.n166 19.0179
R1156 VDD.n165 VDD.n159 19.0179
R1157 VDD.n351 VDD.n349 19.0179
R1158 VDD.n357 VDD.n356 19.0179
R1159 VDD.n78 VDD.n1 18.1338
R1160 VDD.n268 VDD.n267 18.1338
R1161 VDD.n46 VDD.n41 18.0005
R1162 VDD.n40 VDD.n33 18.0005
R1163 VDD.n52 VDD.n32 18.0005
R1164 VDD.n53 VDD.n31 18.0005
R1165 VDD.n54 VDD.n30 18.0005
R1166 VDD.n29 VDD.n25 18.0005
R1167 VDD.n59 VDD.n24 18.0005
R1168 VDD.n60 VDD.n23 18.0005
R1169 VDD.n61 VDD.n22 18.0005
R1170 VDD.n21 VDD.n19 18.0005
R1171 VDD.n20 VDD.n13 18.0005
R1172 VDD.n69 VDD.n12 18.0005
R1173 VDD.n70 VDD.n11 18.0005
R1174 VDD.n71 VDD.n10 18.0005
R1175 VDD.n3 VDD.n2 18.0005
R1176 VDD.n77 VDD.n76 18.0005
R1177 VDD.n192 VDD.n191 18.0005
R1178 VDD.n262 VDD.n261 18.0005
R1179 VDD.n260 VDD.n195 18.0005
R1180 VDD.n259 VDD.n258 18.0005
R1181 VDD.n197 VDD.n196 18.0005
R1182 VDD.n249 VDD.n248 18.0005
R1183 VDD.n247 VDD.n202 18.0005
R1184 VDD.n246 VDD.n245 18.0005
R1185 VDD.n204 VDD.n203 18.0005
R1186 VDD.n240 VDD.n239 18.0005
R1187 VDD.n238 VDD.n207 18.0005
R1188 VDD.n237 VDD.n236 18.0005
R1189 VDD.n209 VDD.n208 18.0005
R1190 VDD.n226 VDD.n225 18.0005
R1191 VDD.n224 VDD.n214 18.0005
R1192 VDD.n223 VDD.n222 18.0005
R1193 VDD.n42 VDD.n38 17.6849
R1194 VDD.n219 VDD.n211 17.6847
R1195 VDD.n49 VDD.n38 16.4218
R1196 VDD.n37 VDD.n36 16.4218
R1197 VDD.n57 VDD.n15 16.4218
R1198 VDD.n64 VDD.n63 16.4218
R1199 VDD.n66 VDD.n65 16.4218
R1200 VDD.n73 VDD.n7 16.4218
R1201 VDD.n265 VDD.n190 16.4218
R1202 VDD.n255 VDD.n254 16.4218
R1203 VDD.n253 VDD.n252 16.4218
R1204 VDD.n243 VDD.n200 16.4218
R1205 VDD.n233 VDD.n232 16.4218
R1206 VDD.n231 VDD.n230 16.4218
R1207 VDD.n212 VDD.n211 16.4218
R1208 VDD.n6 VDD.n0 16.4215
R1209 VDD.n139 VDD.n130 14.8005
R1210 VDD.n126 VDD.n117 14.8005
R1211 VDD.n313 VDD.n304 14.8005
R1212 VDD.n326 VDD.n317 14.8005
R1213 VDD.n120 VDD.n116 14.6065
R1214 VDD.n306 VDD.n303 14.6065
R1215 VDD.t107 VDD.t105 13.3338
R1216 VDD.t105 VDD.t275 13.3338
R1217 VDD.t275 VDD.t273 13.3338
R1218 VDD.t273 VDD.t123 13.3338
R1219 VDD.t123 VDD.t121 13.3338
R1220 VDD.t121 VDD.t322 13.3338
R1221 VDD.t322 VDD.t320 13.3338
R1222 VDD.t199 VDD.t201 13.3338
R1223 VDD.t70 VDD.t195 13.3338
R1224 VDD.t100 VDD.t70 13.3338
R1225 VDD.t46 VDD.t44 13.3338
R1226 VDD.t50 VDD.t46 13.3338
R1227 VDD.t52 VDD.t50 13.3338
R1228 VDD.t304 VDD.t305 13.3338
R1229 VDD.t303 VDD.t304 13.3338
R1230 VDD.t302 VDD.t303 13.3338
R1231 VDD.t301 VDD.t302 13.3338
R1232 VDD.t300 VDD.t301 13.3338
R1233 VDD.t366 VDD.t300 13.3338
R1234 VDD.t365 VDD.t366 13.3338
R1235 VDD.t131 VDD.t129 13.3338
R1236 VDD.t133 VDD.t131 13.3338
R1237 VDD.t135 VDD.t133 13.3338
R1238 VDD.t139 VDD.t137 13.3338
R1239 VDD.t141 VDD.t139 13.3338
R1240 VDD.t141 VDD.t143 13.3338
R1241 VDD.t145 VDD.t146 13.3338
R1242 VDD.t146 VDD.t147 13.3338
R1243 VDD.t147 VDD.t148 13.3338
R1244 VDD.t149 VDD.t150 13.3338
R1245 VDD.t150 VDD.t151 13.3338
R1246 VDD.t151 VDD.t152 13.3338
R1247 VDD.t155 VDD.t153 13.3338
R1248 VDD.t157 VDD.t155 13.3338
R1249 VDD.t159 VDD.t157 13.3338
R1250 VDD.t167 VDD.t165 13.3338
R1251 VDD.t169 VDD.t167 13.3338
R1252 VDD.t171 VDD.t169 13.3338
R1253 VDD.t294 VDD.t99 13.3338
R1254 VDD.t82 VDD.t294 13.3338
R1255 VDD.t213 VDD.t82 13.3338
R1256 VDD.t89 VDD.t213 13.3338
R1257 VDD.t85 VDD.t89 13.3338
R1258 VDD.t98 VDD.t85 13.3338
R1259 VDD.t98 VDD.t86 13.3338
R1260 VDD.t48 VDD.t54 13.3338
R1261 VDD.t54 VDD.t56 13.3338
R1262 VDD.t56 VDD.t60 13.3338
R1263 VDD.t328 VDD.t326 13.3338
R1264 VDD.t326 VDD.t324 13.3338
R1265 VDD.t119 VDD.t109 13.3338
R1266 VDD.t391 VDD.t102 13.3338
R1267 VDD.t389 VDD.t391 13.3338
R1268 VDD.t216 VDD.t389 13.3338
R1269 VDD.t214 VDD.t216 13.3338
R1270 VDD.t265 VDD.t214 13.3338
R1271 VDD.t263 VDD.t265 13.3338
R1272 VDD.t263 VDD.t76 13.3338
R1273 VDD.t367 VDD.t74 13.3338
R1274 VDD.t74 VDD.t72 13.3338
R1275 VDD.t72 VDD.t358 13.3338
R1276 VDD.t358 VDD.t356 13.3338
R1277 VDD.t356 VDD.t182 13.3338
R1278 VDD.t182 VDD.t180 13.3338
R1279 VDD.t180 VDD.t178 13.3338
R1280 VDD.t125 VDD.t193 13.3338
R1281 VDD.t372 VDD.t374 13.3338
R1282 VDD.t378 VDD.t372 13.3338
R1283 VDD.t14 VDD.t12 13.3338
R1284 VDD.t16 VDD.t14 13.3338
R1285 VDD.t18 VDD.t16 13.3338
R1286 VDD.t69 VDD.t260 13.3338
R1287 VDD.t68 VDD.t69 13.3338
R1288 VDD.t268 VDD.t68 13.3338
R1289 VDD.t267 VDD.t268 13.3338
R1290 VDD.t97 VDD.t267 13.3338
R1291 VDD.t96 VDD.t97 13.3338
R1292 VDD.t388 VDD.t96 13.3338
R1293 VDD.t222 VDD.t220 13.3338
R1294 VDD.t224 VDD.t222 13.3338
R1295 VDD.t203 VDD.t224 13.3338
R1296 VDD.t230 VDD.t205 13.3338
R1297 VDD.t232 VDD.t230 13.3338
R1298 VDD.t232 VDD.t228 13.3338
R1299 VDD.t234 VDD.t235 13.3338
R1300 VDD.t235 VDD.t236 13.3338
R1301 VDD.t236 VDD.t207 13.3338
R1302 VDD.t208 VDD.t237 13.3338
R1303 VDD.t237 VDD.t238 13.3338
R1304 VDD.t238 VDD.t239 13.3338
R1305 VDD.t240 VDD.t242 13.3338
R1306 VDD.t242 VDD.t244 13.3338
R1307 VDD.t209 VDD.t244 13.3338
R1308 VDD.t248 VDD.t211 13.3338
R1309 VDD.t250 VDD.t248 13.3338
R1310 VDD.t252 VDD.t250 13.3338
R1311 VDD.t335 VDD.t360 13.3338
R1312 VDD.t334 VDD.t335 13.3338
R1313 VDD.t362 VDD.t334 13.3338
R1314 VDD.t361 VDD.t362 13.3338
R1315 VDD.t337 VDD.t361 13.3338
R1316 VDD.t336 VDD.t337 13.3338
R1317 VDD.t371 VDD.t336 13.3338
R1318 VDD.t28 VDD.t22 13.3338
R1319 VDD.t26 VDD.t28 13.3338
R1320 VDD.t24 VDD.t26 13.3338
R1321 VDD.t191 VDD.t185 13.3338
R1322 VDD.t189 VDD.t191 13.3338
R1323 VDD.t115 VDD.t117 13.3338
R1324 VDD.t332 VDD.t330 13.3338
R1325 VDD.t330 VDD.t344 13.3338
R1326 VDD.t344 VDD.t342 13.3338
R1327 VDD.t342 VDD.t340 13.3338
R1328 VDD.t340 VDD.t338 13.3338
R1329 VDD.t338 VDD.t348 13.3338
R1330 VDD.t348 VDD.t346 13.3338
R1331 VDD.n143 VDD.n141 12.2524
R1332 VDD.n330 VDD.n328 12.2524
R1333 VDD.n149 VDD.n147 11.8107
R1334 VDD.n339 VDD.n337 11.8107
R1335 VDD.n115 VDD.n114 11.7788
R1336 VDD.n302 VDD.n301 11.7788
R1337 VDD.n111 VDD.n110 11.7396
R1338 VDD.n293 VDD.n292 11.7396
R1339 VDD.n172 VDD.t91 11.724
R1340 VDD.n171 VDD.t315 11.724
R1341 VDD.n177 VDD.t309 11.724
R1342 VDD.n170 VDD.t79 11.724
R1343 VDD.n182 VDD.t297 11.724
R1344 VDD.n169 VDD.t112 11.724
R1345 VDD.n187 VDD.t1 11.724
R1346 VDD.n104 VDD.n102 10.5755
R1347 VDD.n281 VDD.n279 10.5755
R1348 VDD.n137 VDD.t288 10.4271
R1349 VDD.n127 VDD.t290 10.4271
R1350 VDD.n314 VDD.t284 10.4271
R1351 VDD.n318 VDD.t286 10.4271
R1352 VDD.n188 VDD.n187 10.4005
R1353 VDD.t201 VDD.n48 10.0005
R1354 VDD.t195 VDD.t161 10.0005
R1355 VDD.t38 VDD.t100 10.0005
R1356 VDD.t40 VDD.t87 10.0005
R1357 VDD.t42 VDD.t127 10.0005
R1358 VDD.t36 VDD.t393 10.0005
R1359 VDD.t44 VDD.t197 10.0005
R1360 VDD.t60 VDD.t363 10.0005
R1361 VDD.t58 VDD.t354 10.0005
R1362 VDD.t62 VDD.t352 10.0005
R1363 VDD.t64 VDD.t350 10.0005
R1364 VDD.t66 VDD.t328 10.0005
R1365 VDD.t324 VDD.t173 10.0005
R1366 VDD.n74 VDD.t119 10.0005
R1367 VDD.n264 VDD.t193 10.0005
R1368 VDD.t374 VDD.t254 10.0005
R1369 VDD.t6 VDD.t378 10.0005
R1370 VDD.t4 VDD.t376 10.0005
R1371 VDD.t8 VDD.t382 10.0005
R1372 VDD.t10 VDD.t380 10.0005
R1373 VDD.t12 VDD.t384 10.0005
R1374 VDD.t386 VDD.t24 10.0005
R1375 VDD.t279 VDD.t20 10.0005
R1376 VDD.t277 VDD.t30 10.0005
R1377 VDD.t187 VDD.t32 10.0005
R1378 VDD.t185 VDD.t34 10.0005
R1379 VDD.t256 VDD.t189 10.0005
R1380 VDD.n220 VDD.t115 10.0005
R1381 VDD.n140 VDD.n139 9.82224
R1382 VDD.n327 VDD.n326 9.82224
R1383 VDD.n44 VDD.n41 9.31191
R1384 VDD.n223 VDD.n215 9.31191
R1385 VDD.n376 VDD.n375 8.7105
R1386 VDD.n189 VDD.n168 7.7305
R1387 VDD.n147 VDD.n81 7.27876
R1388 VDD.n137 VDD.n129 7.27876
R1389 VDD.n128 VDD.n127 7.27876
R1390 VDD.n111 VDD.n85 7.27876
R1391 VDD.n293 VDD.n272 7.27876
R1392 VDD.n315 VDD.n314 7.27876
R1393 VDD.n318 VDD.n316 7.27876
R1394 VDD.n337 VDD.n271 7.27876
R1395 VDD.n138 VDD.n137 7.13872
R1396 VDD.n325 VDD.n318 7.13872
R1397 VDD.n44 VDD.n43 6.79358
R1398 VDD.n218 VDD.n215 6.79358
R1399 VDD.n56 VDD.t163 6.66717
R1400 VDD.t305 VDD.t52 6.66717
R1401 VDD.t129 VDD.t365 6.66717
R1402 VDD.n57 VDD.t135 6.66717
R1403 VDD.t137 VDD.n57 6.66717
R1404 VDD.t148 VDD.n27 6.66717
R1405 VDD.n27 VDD.t149 6.66717
R1406 VDD.n63 VDD.t159 6.66717
R1407 VDD.n63 VDD.t165 6.66717
R1408 VDD.t99 VDD.t171 6.66717
R1409 VDD.t86 VDD.t48 6.66717
R1410 VDD.n16 VDD.t175 6.66717
R1411 VDD.t218 VDD.n251 6.66717
R1412 VDD.t260 VDD.t18 6.66717
R1413 VDD.t220 VDD.t388 6.66717
R1414 VDD.n243 VDD.t203 6.66717
R1415 VDD.t205 VDD.n243 6.66717
R1416 VDD.t207 VDD.n242 6.66717
R1417 VDD.n242 VDD.t208 6.66717
R1418 VDD.n233 VDD.t209 6.66717
R1419 VDD.t211 VDD.n233 6.66717
R1420 VDD.t360 VDD.t252 6.66717
R1421 VDD.t22 VDD.t371 6.66717
R1422 VDD.n234 VDD.t258 6.66717
R1423 VDD.t105 VDD.n39 6.3005
R1424 VDD.n45 VDD.n39 6.3005
R1425 VDD.n48 VDD.n47 6.3005
R1426 VDD.n47 VDD.n46 6.3005
R1427 VDD.n49 VDD.n34 6.3005
R1428 VDD.n34 VDD.n33 6.3005
R1429 VDD.n51 VDD.n50 6.3005
R1430 VDD.n52 VDD.n51 6.3005
R1431 VDD.n35 VDD.n28 6.3005
R1432 VDD.n53 VDD.n28 6.3005
R1433 VDD.n56 VDD.n55 6.3005
R1434 VDD.n55 VDD.n54 6.3005
R1435 VDD.t304 VDD.n26 6.3005
R1436 VDD.n26 VDD.n25 6.3005
R1437 VDD.n58 VDD.t141 6.3005
R1438 VDD.n59 VDD.n58 6.3005
R1439 VDD.n27 VDD.n18 6.3005
R1440 VDD.n60 VDD.n18 6.3005
R1441 VDD.t155 VDD.n62 6.3005
R1442 VDD.n62 VDD.n61 6.3005
R1443 VDD.n17 VDD.t98 6.3005
R1444 VDD.n19 VDD.n17 6.3005
R1445 VDD.n16 VDD.n14 6.3005
R1446 VDD.n14 VDD.n13 6.3005
R1447 VDD.n68 VDD.n67 6.3005
R1448 VDD.n69 VDD.n68 6.3005
R1449 VDD.n9 VDD.n8 6.3005
R1450 VDD.n70 VDD.n9 6.3005
R1451 VDD.n73 VDD.n72 6.3005
R1452 VDD.n72 VDD.n71 6.3005
R1453 VDD.n74 VDD.n5 6.3005
R1454 VDD.n5 VDD.n3 6.3005
R1455 VDD.n75 VDD.t263 6.3005
R1456 VDD.n76 VDD.n75 6.3005
R1457 VDD.n4 VDD.n1 6.3005
R1458 VDD.t348 VDD.n217 6.3005
R1459 VDD.n217 VDD.n216 6.3005
R1460 VDD.n221 VDD.n220 6.3005
R1461 VDD.n222 VDD.n221 6.3005
R1462 VDD.n213 VDD.n212 6.3005
R1463 VDD.n214 VDD.n213 6.3005
R1464 VDD.n228 VDD.n227 6.3005
R1465 VDD.n227 VDD.n226 6.3005
R1466 VDD.n229 VDD.n210 6.3005
R1467 VDD.n210 VDD.n209 6.3005
R1468 VDD.n235 VDD.n234 6.3005
R1469 VDD.n236 VDD.n235 6.3005
R1470 VDD.t336 VDD.n206 6.3005
R1471 VDD.n207 VDD.n206 6.3005
R1472 VDD.t242 VDD.n241 6.3005
R1473 VDD.n241 VDD.n240 6.3005
R1474 VDD.n242 VDD.n205 6.3005
R1475 VDD.n205 VDD.n204 6.3005
R1476 VDD.n244 VDD.t232 6.3005
R1477 VDD.n245 VDD.n244 6.3005
R1478 VDD.t69 VDD.n201 6.3005
R1479 VDD.n202 VDD.n201 6.3005
R1480 VDD.n251 VDD.n250 6.3005
R1481 VDD.n250 VDD.n249 6.3005
R1482 VDD.n199 VDD.n198 6.3005
R1483 VDD.n198 VDD.n197 6.3005
R1484 VDD.n257 VDD.n256 6.3005
R1485 VDD.n258 VDD.n257 6.3005
R1486 VDD.n255 VDD.n194 6.3005
R1487 VDD.n195 VDD.n194 6.3005
R1488 VDD.n264 VDD.n263 6.3005
R1489 VDD.n263 VDD.n262 6.3005
R1490 VDD.t74 VDD.n193 6.3005
R1491 VDD.n193 VDD.n192 6.3005
R1492 VDD.n267 VDD.n266 6.3005
R1493 VDD.n168 VDD.n167 5.66103
R1494 VDD.n358 VDD.n357 5.66103
R1495 VDD.n162 VDD.n160 5.51014
R1496 VDD.n84 VDD.n82 5.51014
R1497 VDD.n133 VDD.n131 5.51014
R1498 VDD.n93 VDD.n91 5.51014
R1499 VDD.n88 VDD.n86 5.51014
R1500 VDD.n98 VDD.n96 5.51014
R1501 VDD.n276 VDD.n274 5.51014
R1502 VDD.n298 VDD.n296 5.51014
R1503 VDD.n291 VDD.n289 5.51014
R1504 VDD.n321 VDD.n319 5.51014
R1505 VDD.n335 VDD.n333 5.51014
R1506 VDD.n354 VDD.n352 5.51014
R1507 VDD.n102 VDD.n101 5.4159
R1508 VDD.n279 VDD.n273 5.4159
R1509 VDD.n162 VDD.n161 5.32067
R1510 VDD.n166 VDD.n163 5.32067
R1511 VDD.n165 VDD.n164 5.32067
R1512 VDD.n84 VDD.n83 5.32067
R1513 VDD.n145 VDD.n144 5.32067
R1514 VDD.n143 VDD.n142 5.32067
R1515 VDD.n155 VDD.n154 5.32067
R1516 VDD.n153 VDD.n152 5.32067
R1517 VDD.n151 VDD.n150 5.32067
R1518 VDD.n149 VDD.n148 5.32067
R1519 VDD.n133 VDD.n132 5.32067
R1520 VDD.n135 VDD.n134 5.32067
R1521 VDD.n138 VDD.n136 5.32067
R1522 VDD.n125 VDD.n118 5.32067
R1523 VDD.n124 VDD.n123 5.32067
R1524 VDD.n122 VDD.n121 5.32067
R1525 VDD.n120 VDD.n119 5.32067
R1526 VDD.n93 VDD.n92 5.32067
R1527 VDD.n109 VDD.n108 5.32067
R1528 VDD.n107 VDD.n106 5.32067
R1529 VDD.n88 VDD.n87 5.32067
R1530 VDD.n90 VDD.n89 5.32067
R1531 VDD.n113 VDD.n112 5.32067
R1532 VDD.n98 VDD.n97 5.32067
R1533 VDD.n100 VDD.n99 5.32067
R1534 VDD.n278 VDD.n277 5.32067
R1535 VDD.n276 VDD.n275 5.32067
R1536 VDD.n295 VDD.n294 5.32067
R1537 VDD.n300 VDD.n299 5.32067
R1538 VDD.n298 VDD.n297 5.32067
R1539 VDD.n286 VDD.n285 5.32067
R1540 VDD.n288 VDD.n287 5.32067
R1541 VDD.n291 VDD.n290 5.32067
R1542 VDD.n306 VDD.n305 5.32067
R1543 VDD.n308 VDD.n307 5.32067
R1544 VDD.n310 VDD.n309 5.32067
R1545 VDD.n312 VDD.n311 5.32067
R1546 VDD.n325 VDD.n324 5.32067
R1547 VDD.n323 VDD.n322 5.32067
R1548 VDD.n321 VDD.n320 5.32067
R1549 VDD.n339 VDD.n338 5.32067
R1550 VDD.n341 VDD.n340 5.32067
R1551 VDD.n343 VDD.n342 5.32067
R1552 VDD.n345 VDD.n344 5.32067
R1553 VDD.n330 VDD.n329 5.32067
R1554 VDD.n332 VDD.n331 5.32067
R1555 VDD.n335 VDD.n334 5.32067
R1556 VDD.n351 VDD.n350 5.32067
R1557 VDD.n356 VDD.n355 5.32067
R1558 VDD.n354 VDD.n353 5.32067
R1559 VDD.n189 VDD.n188 4.651
R1560 VDD.n113 VDD.n111 4.59524
R1561 VDD.n295 VDD.n293 4.59524
R1562 VDD.n147 VDD.n146 4.5005
R1563 VDD.n139 VDD.n138 4.5005
R1564 VDD.n126 VDD.n125 4.5005
R1565 VDD.n313 VDD.n312 4.5005
R1566 VDD.n326 VDD.n325 4.5005
R1567 VDD.n337 VDD.n336 4.5005
R1568 VDD.n105 VDD.n104 4.31103
R1569 VDD.n284 VDD.n281 4.31103
R1570 VDD.n158 VDD.n156 4.12155
R1571 VDD.n348 VDD.n346 4.12155
R1572 VDD.n375 VDD.n358 4.0105
R1573 VDD.t83 VDD.n56 3.33383
R1574 VDD.t161 VDD.t83 3.33383
R1575 VDD.t87 VDD.t38 3.33383
R1576 VDD.t127 VDD.t40 3.33383
R1577 VDD.t393 VDD.t42 3.33383
R1578 VDD.t197 VDD.t36 3.33383
R1579 VDD.t363 VDD.t58 3.33383
R1580 VDD.t354 VDD.t62 3.33383
R1581 VDD.t352 VDD.t64 3.33383
R1582 VDD.t350 VDD.t66 3.33383
R1583 VDD.t173 VDD.t306 3.33383
R1584 VDD.t306 VDD.n16 3.33383
R1585 VDD.n251 VDD.t369 3.33383
R1586 VDD.t254 VDD.t369 3.33383
R1587 VDD.t376 VDD.t6 3.33383
R1588 VDD.t382 VDD.t4 3.33383
R1589 VDD.t380 VDD.t8 3.33383
R1590 VDD.t384 VDD.t10 3.33383
R1591 VDD.t20 VDD.t386 3.33383
R1592 VDD.t30 VDD.t279 3.33383
R1593 VDD.t32 VDD.t277 3.33383
R1594 VDD.t34 VDD.t187 3.33383
R1595 VDD.t318 VDD.t256 3.33383
R1596 VDD.n234 VDD.t318 3.33383
R1597 VDD.n373 VDD.n369 3.0962
R1598 VDD.n127 VDD.n126 2.54398
R1599 VDD.n314 VDD.n313 2.54398
R1600 VDD.n372 VDD.n370 2.26494
R1601 VDD.n373 VDD.n372 2.20416
R1602 VDD.n129 VDD.n128 2.17945
R1603 VDD.n316 VDD.n315 2.17945
R1604 VDD.n375 VDD.n374 1.69099
R1605 VDD.n38 VDD.n37 1.26366
R1606 VDD.n37 VDD.n15 1.26366
R1607 VDD.n64 VDD.n15 1.26366
R1608 VDD.n65 VDD.n64 1.26366
R1609 VDD.n65 VDD.n7 1.26366
R1610 VDD.n7 VDD.n0 1.26366
R1611 VDD.n254 VDD.n190 1.26366
R1612 VDD.n254 VDD.n253 1.26366
R1613 VDD.n253 VDD.n200 1.26366
R1614 VDD.n232 VDD.n200 1.26366
R1615 VDD.n232 VDD.n231 1.26366
R1616 VDD.n231 VDD.n211 1.26366
R1617 VDD.n116 VDD.n115 1.04261
R1618 VDD.n303 VDD.n302 1.04261
R1619 VDD.n360 VDD.n359 1.03676
R1620 VDD.n46 VDD.n45 1.0005
R1621 VDD.n46 VDD.n33 1.0005
R1622 VDD.n52 VDD.n33 1.0005
R1623 VDD.n53 VDD.n52 1.0005
R1624 VDD.n54 VDD.n53 1.0005
R1625 VDD.n54 VDD.n25 1.0005
R1626 VDD.n59 VDD.n25 1.0005
R1627 VDD.n60 VDD.n59 1.0005
R1628 VDD.n61 VDD.n60 1.0005
R1629 VDD.n61 VDD.n19 1.0005
R1630 VDD.n19 VDD.n13 1.0005
R1631 VDD.n69 VDD.n13 1.0005
R1632 VDD.n70 VDD.n69 1.0005
R1633 VDD.n71 VDD.n70 1.0005
R1634 VDD.n71 VDD.n3 1.0005
R1635 VDD.n76 VDD.n3 1.0005
R1636 VDD.n76 VDD.n1 1.0005
R1637 VDD.n267 VDD.n192 1.0005
R1638 VDD.n262 VDD.n192 1.0005
R1639 VDD.n262 VDD.n195 1.0005
R1640 VDD.n258 VDD.n195 1.0005
R1641 VDD.n258 VDD.n197 1.0005
R1642 VDD.n249 VDD.n197 1.0005
R1643 VDD.n249 VDD.n202 1.0005
R1644 VDD.n245 VDD.n202 1.0005
R1645 VDD.n245 VDD.n204 1.0005
R1646 VDD.n240 VDD.n204 1.0005
R1647 VDD.n240 VDD.n207 1.0005
R1648 VDD.n236 VDD.n207 1.0005
R1649 VDD.n236 VDD.n209 1.0005
R1650 VDD.n226 VDD.n209 1.0005
R1651 VDD.n226 VDD.n214 1.0005
R1652 VDD.n222 VDD.n214 1.0005
R1653 VDD.n222 VDD.n216 1.0005
R1654 VDD.n141 VDD.n140 0.947868
R1655 VDD.n328 VDD.n327 0.947868
R1656 VDD.n374 VDD.n361 0.884153
R1657 VDD.n159 VDD.n158 0.876816
R1658 VDD.n349 VDD.n348 0.876816
R1659 VDD.n128 VDD.n116 0.853132
R1660 VDD.n315 VDD.n303 0.853132
R1661 VDD.n173 VDD.n172 0.8005
R1662 VDD.n176 VDD.n171 0.8005
R1663 VDD.n178 VDD.n177 0.8005
R1664 VDD.n181 VDD.n170 0.8005
R1665 VDD.n183 VDD.n182 0.8005
R1666 VDD.n186 VDD.n169 0.8005
R1667 VDD.n141 VDD.n81 0.758395
R1668 VDD.n328 VDD.n271 0.758395
R1669 VDD.n374 VDD.n373 0.745997
R1670 VDD.n156 VDD.n80 0.592605
R1671 VDD.n346 VDD.n270 0.592605
R1672 VDD.n95 VDD.n85 0.521553
R1673 VDD.n81 VDD.n80 0.521553
R1674 VDD.n271 VDD.n270 0.521553
R1675 VDD.n283 VDD.n272 0.521553
R1676 VDD.n45 VDD.n44 0.481712
R1677 VDD.n216 VDD.n215 0.481712
R1678 VDD.n365 VDD.n364 0.451962
R1679 VDD.n41 VDD.n40 0.444944
R1680 VDD.n40 VDD.n32 0.444944
R1681 VDD.n32 VDD.n31 0.444944
R1682 VDD.n31 VDD.n30 0.444944
R1683 VDD.n30 VDD.n29 0.444944
R1684 VDD.n29 VDD.n24 0.444944
R1685 VDD.n24 VDD.n23 0.444944
R1686 VDD.n23 VDD.n22 0.444944
R1687 VDD.n22 VDD.n21 0.444944
R1688 VDD.n21 VDD.n20 0.444944
R1689 VDD.n20 VDD.n12 0.444944
R1690 VDD.n12 VDD.n11 0.444944
R1691 VDD.n11 VDD.n10 0.444944
R1692 VDD.n10 VDD.n2 0.444944
R1693 VDD.n77 VDD.n2 0.444944
R1694 VDD.n261 VDD.n191 0.444944
R1695 VDD.n261 VDD.n260 0.444944
R1696 VDD.n260 VDD.n259 0.444944
R1697 VDD.n259 VDD.n196 0.444944
R1698 VDD.n248 VDD.n196 0.444944
R1699 VDD.n248 VDD.n247 0.444944
R1700 VDD.n247 VDD.n246 0.444944
R1701 VDD.n246 VDD.n203 0.444944
R1702 VDD.n239 VDD.n203 0.444944
R1703 VDD.n239 VDD.n238 0.444944
R1704 VDD.n238 VDD.n237 0.444944
R1705 VDD.n237 VDD.n208 0.444944
R1706 VDD.n225 VDD.n208 0.444944
R1707 VDD.n225 VDD.n224 0.444944
R1708 VDD.n224 VDD.n223 0.444944
R1709 VDD.n363 VDD.n362 0.356056
R1710 VDD.n364 VDD.n363 0.356056
R1711 VDD.n361 VDD.n360 0.337342
R1712 VDD.n78 VDD.n77 0.311611
R1713 VDD.n268 VDD.n191 0.311611
R1714 VDD.n160 VDD.t264 0.228
R1715 VDD.n160 VDD.t77 0.228
R1716 VDD.n161 VDD.t215 0.228
R1717 VDD.n161 VDD.t266 0.228
R1718 VDD.n163 VDD.t390 0.228
R1719 VDD.n163 VDD.t217 0.228
R1720 VDD.n164 VDD.t103 0.228
R1721 VDD.n164 VDD.t392 0.228
R1722 VDD.n157 VDD.t110 0.228
R1723 VDD.n157 VDD.t120 0.228
R1724 VDD.n82 VDD.t65 0.228
R1725 VDD.n82 VDD.t67 0.228
R1726 VDD.n83 VDD.t59 0.228
R1727 VDD.n83 VDD.t63 0.228
R1728 VDD.n144 VDD.t57 0.228
R1729 VDD.n144 VDD.t61 0.228
R1730 VDD.n142 VDD.t49 0.228
R1731 VDD.n142 VDD.t55 0.228
R1732 VDD.n154 VDD.t325 0.228
R1733 VDD.n154 VDD.t307 0.228
R1734 VDD.n152 VDD.t329 0.228
R1735 VDD.n152 VDD.t327 0.228
R1736 VDD.n150 VDD.t353 0.228
R1737 VDD.n150 VDD.t351 0.228
R1738 VDD.n148 VDD.t364 0.228
R1739 VDD.n148 VDD.t355 0.228
R1740 VDD.n79 VDD.t174 0.228
R1741 VDD.n79 VDD.t176 0.228
R1742 VDD.n130 VDD.t272 0.228
R1743 VDD.n130 VDD.t269 0.228
R1744 VDD.n131 VDD.t170 0.228
R1745 VDD.n131 VDD.t172 0.228
R1746 VDD.n132 VDD.t166 0.228
R1747 VDD.n132 VDD.t168 0.228
R1748 VDD.n134 VDD.t158 0.228
R1749 VDD.n134 VDD.t160 0.228
R1750 VDD.n136 VDD.t154 0.228
R1751 VDD.n136 VDD.t156 0.228
R1752 VDD.n117 VDD.t270 0.228
R1753 VDD.n117 VDD.t271 0.228
R1754 VDD.n118 VDD.t142 0.228
R1755 VDD.n118 VDD.t144 0.228
R1756 VDD.n123 VDD.t138 0.228
R1757 VDD.n123 VDD.t140 0.228
R1758 VDD.n121 VDD.t134 0.228
R1759 VDD.n121 VDD.t136 0.228
R1760 VDD.n119 VDD.t130 0.228
R1761 VDD.n119 VDD.t132 0.228
R1762 VDD.n91 VDD.t394 0.228
R1763 VDD.n91 VDD.t198 0.228
R1764 VDD.n92 VDD.t88 0.228
R1765 VDD.n92 VDD.t128 0.228
R1766 VDD.n108 VDD.t71 0.228
R1767 VDD.n108 VDD.t101 0.228
R1768 VDD.n106 VDD.t84 0.228
R1769 VDD.n106 VDD.t196 0.228
R1770 VDD.n86 VDD.t51 0.228
R1771 VDD.n86 VDD.t53 0.228
R1772 VDD.n87 VDD.t45 0.228
R1773 VDD.n87 VDD.t47 0.228
R1774 VDD.n89 VDD.t43 0.228
R1775 VDD.n89 VDD.t37 0.228
R1776 VDD.n112 VDD.t39 0.228
R1777 VDD.n112 VDD.t41 0.228
R1778 VDD.n94 VDD.t164 0.228
R1779 VDD.n94 VDD.t162 0.228
R1780 VDD.n103 VDD.t202 0.228
R1781 VDD.n103 VDD.t200 0.228
R1782 VDD.n96 VDD.t323 0.228
R1783 VDD.n96 VDD.t321 0.228
R1784 VDD.n97 VDD.t124 0.228
R1785 VDD.n97 VDD.t122 0.228
R1786 VDD.n99 VDD.t276 0.228
R1787 VDD.n99 VDD.t274 0.228
R1788 VDD.n101 VDD.t108 0.228
R1789 VDD.n101 VDD.t106 0.228
R1790 VDD.n273 VDD.t349 0.228
R1791 VDD.n273 VDD.t347 0.228
R1792 VDD.n277 VDD.t341 0.228
R1793 VDD.n277 VDD.t339 0.228
R1794 VDD.n275 VDD.t345 0.228
R1795 VDD.n275 VDD.t343 0.228
R1796 VDD.n274 VDD.t333 0.228
R1797 VDD.n274 VDD.t331 0.228
R1798 VDD.n280 VDD.t118 0.228
R1799 VDD.n280 VDD.t116 0.228
R1800 VDD.n294 VDD.t33 0.228
R1801 VDD.n294 VDD.t35 0.228
R1802 VDD.n299 VDD.t21 0.228
R1803 VDD.n299 VDD.t31 0.228
R1804 VDD.n297 VDD.t27 0.228
R1805 VDD.n297 VDD.t25 0.228
R1806 VDD.n296 VDD.t23 0.228
R1807 VDD.n296 VDD.t29 0.228
R1808 VDD.n285 VDD.t190 0.228
R1809 VDD.n285 VDD.t319 0.228
R1810 VDD.n287 VDD.t186 0.228
R1811 VDD.n287 VDD.t192 0.228
R1812 VDD.n290 VDD.t278 0.228
R1813 VDD.n290 VDD.t188 0.228
R1814 VDD.n289 VDD.t387 0.228
R1815 VDD.n289 VDD.t280 0.228
R1816 VDD.n282 VDD.t257 0.228
R1817 VDD.n282 VDD.t259 0.228
R1818 VDD.n305 VDD.t251 0.228
R1819 VDD.n305 VDD.t253 0.228
R1820 VDD.n307 VDD.t247 0.228
R1821 VDD.n307 VDD.t249 0.228
R1822 VDD.n309 VDD.t245 0.228
R1823 VDD.n309 VDD.t246 0.228
R1824 VDD.n304 VDD.t210 0.228
R1825 VDD.n304 VDD.t212 0.228
R1826 VDD.n311 VDD.t241 0.228
R1827 VDD.n311 VDD.t243 0.228
R1828 VDD.n317 VDD.t204 0.228
R1829 VDD.n317 VDD.t206 0.228
R1830 VDD.n324 VDD.t233 0.228
R1831 VDD.n324 VDD.t229 0.228
R1832 VDD.n322 VDD.t227 0.228
R1833 VDD.n322 VDD.t231 0.228
R1834 VDD.n320 VDD.t225 0.228
R1835 VDD.n320 VDD.t226 0.228
R1836 VDD.n319 VDD.t221 0.228
R1837 VDD.n319 VDD.t223 0.228
R1838 VDD.n338 VDD.t381 0.228
R1839 VDD.n338 VDD.t385 0.228
R1840 VDD.n340 VDD.t377 0.228
R1841 VDD.n340 VDD.t383 0.228
R1842 VDD.n342 VDD.t373 0.228
R1843 VDD.n342 VDD.t379 0.228
R1844 VDD.n344 VDD.t370 0.228
R1845 VDD.n344 VDD.t375 0.228
R1846 VDD.n329 VDD.t17 0.228
R1847 VDD.n329 VDD.t19 0.228
R1848 VDD.n331 VDD.t13 0.228
R1849 VDD.n331 VDD.t15 0.228
R1850 VDD.n334 VDD.t9 0.228
R1851 VDD.n334 VDD.t11 0.228
R1852 VDD.n333 VDD.t7 0.228
R1853 VDD.n333 VDD.t5 0.228
R1854 VDD.n269 VDD.t219 0.228
R1855 VDD.n269 VDD.t255 0.228
R1856 VDD.n347 VDD.t194 0.228
R1857 VDD.n347 VDD.t126 0.228
R1858 VDD.n350 VDD.t181 0.228
R1859 VDD.n350 VDD.t179 0.228
R1860 VDD.n355 VDD.t357 0.228
R1861 VDD.n355 VDD.t183 0.228
R1862 VDD.n353 VDD.t73 0.228
R1863 VDD.n353 VDD.t359 0.228
R1864 VDD.n352 VDD.t368 0.228
R1865 VDD.n352 VDD.t75 0.228
R1866 VDD.n372 VDD.n371 0.227751
R1867 VDD.n105 VDD.n95 0.213658
R1868 VDD.n284 VDD.n283 0.213658
R1869 VDD.n168 VDD.n0 0.191026
R1870 VDD.n358 VDD.n190 0.191026
R1871 VDD.n115 VDD.n85 0.189974
R1872 VDD.n167 VDD.n159 0.189974
R1873 VDD.n166 VDD.n165 0.189974
R1874 VDD.n166 VDD.n162 0.189974
R1875 VDD.n151 VDD.n149 0.189974
R1876 VDD.n153 VDD.n151 0.189974
R1877 VDD.n155 VDD.n153 0.189974
R1878 VDD.n145 VDD.n143 0.189974
R1879 VDD.n138 VDD.n135 0.189974
R1880 VDD.n135 VDD.n133 0.189974
R1881 VDD.n122 VDD.n120 0.189974
R1882 VDD.n124 VDD.n122 0.189974
R1883 VDD.n125 VDD.n124 0.189974
R1884 VDD.n90 VDD.n88 0.189974
R1885 VDD.n109 VDD.n107 0.189974
R1886 VDD.n100 VDD.n98 0.189974
R1887 VDD.n357 VDD.n349 0.189974
R1888 VDD.n302 VDD.n272 0.189974
R1889 VDD.n278 VDD.n276 0.189974
R1890 VDD.n288 VDD.n286 0.189974
R1891 VDD.n300 VDD.n298 0.189974
R1892 VDD.n312 VDD.n310 0.189974
R1893 VDD.n310 VDD.n308 0.189974
R1894 VDD.n308 VDD.n306 0.189974
R1895 VDD.n323 VDD.n321 0.189974
R1896 VDD.n325 VDD.n323 0.189974
R1897 VDD.n332 VDD.n330 0.189974
R1898 VDD.n345 VDD.n343 0.189974
R1899 VDD.n343 VDD.n341 0.189974
R1900 VDD.n341 VDD.n339 0.189974
R1901 VDD.n356 VDD.n354 0.189974
R1902 VDD.n356 VDD.n351 0.189974
R1903 VDD.n366 VDD.n365 0.168921
R1904 VDD.n367 VDD.n366 0.168921
R1905 VDD.n368 VDD.n367 0.168921
R1906 VDD.n110 VDD.n93 0.118921
R1907 VDD.n292 VDD.n291 0.118921
R1908 VDD.n376 VDD.n189 0.1105
R1909 VDD.n173 VDD.n171 0.1005
R1910 VDD.n177 VDD.n176 0.1005
R1911 VDD.n178 VDD.n170 0.1005
R1912 VDD.n182 VDD.n181 0.1005
R1913 VDD.n183 VDD.n169 0.1005
R1914 VDD.n187 VDD.n186 0.1005
R1915 VDD.n140 VDD.n129 0.0952368
R1916 VDD.n146 VDD.n145 0.0952368
R1917 VDD.n146 VDD.n84 0.0952368
R1918 VDD.n114 VDD.n113 0.0952368
R1919 VDD.n114 VDD.n90 0.0952368
R1920 VDD.n327 VDD.n316 0.0952368
R1921 VDD.n301 VDD.n300 0.0952368
R1922 VDD.n301 VDD.n295 0.0952368
R1923 VDD.n336 VDD.n335 0.0952368
R1924 VDD.n336 VDD.n332 0.0952368
R1925 VDD.n102 VDD.n100 0.0948023
R1926 VDD.n279 VDD.n278 0.0948023
R1927 VDD.n110 VDD.n109 0.0715526
R1928 VDD.n292 VDD.n288 0.0715526
R1929 VDD.n369 VDD.n368 0.0678684
R1930 VDD.n168 VDD.n78 0.0505
R1931 VDD.n358 VDD.n268 0.0505
R1932 VDD VDD.n376 0.0205
R1933 VSS.n914 VSS.t178 48139.4
R1934 VSS.n915 VSS.n914 47272.7
R1935 VSS.n463 VSS.n462 5590
R1936 VSS.t165 VSS.t334 3033.33
R1937 VSS.n957 VSS.n231 2405.38
R1938 VSS.n906 VSS.n905 2325.9
R1939 VSS.t334 VSS.t159 1733.33
R1940 VSS.n455 VSS.n422 1618.73
R1941 VSS.n401 VSS.t165 1462.5
R1942 VSS.t159 VSS.t15 1300
R1943 VSS.n263 VSS.n249 1266.62
R1944 VSS.n463 VSS.t178 996.668
R1945 VSS.t169 VSS.t88 878.379
R1946 VSS.n916 VSS.n263 780
R1947 VSS.n288 VSS.n266 780
R1948 VSS.n265 VSS.n264 780
R1949 VSS.n913 VSS.n266 715
R1950 VSS.n288 VSS.n282 651.125
R1951 VSS.n462 VSS.n401 617.5
R1952 VSS.n916 VSS.n915 507
R1953 VSS.t88 VSS.t162 501.932
R1954 VSS.n905 VSS.n311 465.916
R1955 VSS.n401 VSS.t169 423.505
R1956 VSS.t162 VSS.t138 376.449
R1957 VSS.t98 VSS.n913 330.079
R1958 VSS.n937 VSS.n933 296.139
R1959 VSS.n936 VSS.n935 296.139
R1960 VSS.n944 VSS.n943 296.139
R1961 VSS.n946 VSS.n945 296.139
R1962 VSS.n949 VSS.n242 296.139
R1963 VSS.n955 VSS.n236 296.139
R1964 VSS.n913 VSS.t0 279.298
R1965 VSS.n915 VSS.n264 273
R1966 VSS.n912 VSS.n268 234.94
R1967 VSS.n913 VSS.n912 215.362
R1968 VSS.n861 VSS.n267 211.446
R1969 VSS.n421 VSS.n420 204.55
R1970 VSS.n906 VSS.n268 180.12
R1971 VSS.n455 VSS.n401 178.814
R1972 VSS.n930 VSS.n249 163.127
R1973 VSS.n369 VSS.t372 152.136
R1974 VSS.n37 VSS.t369 152.136
R1975 VSS.n363 VSS.t371 149.395
R1976 VSS.n28 VSS.t370 149.395
R1977 VSS.n294 VSS.n282 134.948
R1978 VSS.n295 VSS.n294 134.948
R1979 VSS.n296 VSS.n295 134.948
R1980 VSS.n296 VSS.n278 134.948
R1981 VSS.n302 VSS.n278 134.948
R1982 VSS.n303 VSS.n302 134.948
R1983 VSS.n304 VSS.n303 134.948
R1984 VSS.n304 VSS.n274 134.948
R1985 VSS.n310 VSS.n274 134.948
R1986 VSS.n311 VSS.n310 134.948
R1987 VSS.n422 VSS.n421 116.713
R1988 VSS.n931 VSS.n930 107.915
R1989 VSS.n933 VSS.n932 107.915
R1990 VSS.n935 VSS.n934 107.915
R1991 VSS.n943 VSS.n243 107.915
R1992 VSS.n947 VSS.n946 107.915
R1993 VSS.n949 VSS.n948 107.915
R1994 VSS.n420 VSS.n419 107.915
R1995 VSS.n421 VSS.n418 91.1502
R1996 VSS.n904 VSS.n314 91.0369
R1997 VSS.n997 VSS.n996 91.0369
R1998 VSS.n997 VSS.n113 91.0369
R1999 VSS.n1021 VSS.n97 91.0369
R2000 VSS.n1022 VSS.n1021 91.0369
R2001 VSS.n990 VSS.n117 87.5005
R2002 VSS.n994 VSS.n117 87.5005
R2003 VSS.n994 VSS.n112 87.5005
R2004 VSS.n998 VSS.n112 87.5005
R2005 VSS.n998 VSS.n110 87.5005
R2006 VSS.n1002 VSS.n110 87.5005
R2007 VSS.n1002 VSS.n106 87.5005
R2008 VSS.n1007 VSS.n106 87.5005
R2009 VSS.n1007 VSS.n104 87.5005
R2010 VSS.n1011 VSS.n104 87.5005
R2011 VSS.n1011 VSS.n100 87.5005
R2012 VSS.n1016 VSS.n100 87.5005
R2013 VSS.n1016 VSS.n98 87.5005
R2014 VSS.n1020 VSS.n98 87.5005
R2015 VSS.n1020 VSS.n92 87.5005
R2016 VSS.n1024 VSS.n92 87.5005
R2017 VSS.n1024 VSS.n66 87.5005
R2018 VSS.n1028 VSS.n66 87.5005
R2019 VSS.n73 VSS.n62 87.5005
R2020 VSS.n77 VSS.n71 87.5005
R2021 VSS.n80 VSS.n79 87.5005
R2022 VSS.n84 VSS.n68 87.5005
R2023 VSS.n88 VSS.n86 87.5005
R2024 VSS.n218 VSS.n120 87.5005
R2025 VSS.n218 VSS.n116 87.5005
R2026 VSS.n116 VSS.n115 87.5005
R2027 VSS.n115 VSS.n114 87.5005
R2028 VSS.n223 VSS.n114 87.5005
R2029 VSS.n223 VSS.n109 87.5005
R2030 VSS.n109 VSS.n108 87.5005
R2031 VSS.n108 VSS.n107 87.5005
R2032 VSS.n229 VSS.n107 87.5005
R2033 VSS.n229 VSS.n103 87.5005
R2034 VSS.n103 VSS.n102 87.5005
R2035 VSS.n102 VSS.n101 87.5005
R2036 VSS.n144 VSS.n101 87.5005
R2037 VSS.n144 VSS.n96 87.5005
R2038 VSS.n96 VSS.n95 87.5005
R2039 VSS.n95 VSS.n94 87.5005
R2040 VSS.n94 VSS.n63 87.5005
R2041 VSS.n1030 VSS.n63 87.5005
R2042 VSS.n157 VSS.n150 87.5005
R2043 VSS.n161 VSS.n160 87.5005
R2044 VSS.n165 VSS.n164 87.5005
R2045 VSS.n169 VSS.n155 87.5005
R2046 VSS.n895 VSS.n319 87.5005
R2047 VSS.n899 VSS.n319 87.5005
R2048 VSS.n899 VSS.n316 87.5005
R2049 VSS.n903 VSS.n316 87.5005
R2050 VSS.n903 VSS.n315 87.5005
R2051 VSS.n822 VSS.n315 87.5005
R2052 VSS.n822 VSS.n488 87.5005
R2053 VSS.n826 VSS.n488 87.5005
R2054 VSS.n826 VSS.n482 87.5005
R2055 VSS.n830 VSS.n482 87.5005
R2056 VSS.n830 VSS.n479 87.5005
R2057 VSS.n834 VSS.n479 87.5005
R2058 VSS.n834 VSS.n478 87.5005
R2059 VSS.n800 VSS.n478 87.5005
R2060 VSS.n800 VSS.n496 87.5005
R2061 VSS.n796 VSS.n496 87.5005
R2062 VSS.n796 VSS.n498 87.5005
R2063 VSS.n567 VSS.n498 87.5005
R2064 VSS.n581 VSS.n564 87.5005
R2065 VSS.n584 VSS.n564 87.5005
R2066 VSS.n588 VSS.n587 87.5005
R2067 VSS.n592 VSS.n591 87.5005
R2068 VSS.n594 VSS.n566 87.5005
R2069 VSS.n322 VSS.n321 87.5005
R2070 VSS.n321 VSS.n320 87.5005
R2071 VSS.n815 VSS.n320 87.5005
R2072 VSS.n815 VSS.n313 87.5005
R2073 VSS.n491 VSS.n313 87.5005
R2074 VSS.n820 VSS.n491 87.5005
R2075 VSS.n820 VSS.n490 87.5005
R2076 VSS.n490 VSS.n486 87.5005
R2077 VSS.n486 VSS.n485 87.5005
R2078 VSS.n485 VSS.n484 87.5005
R2079 VSS.n807 VSS.n484 87.5005
R2080 VSS.n807 VSS.n477 87.5005
R2081 VSS.n803 VSS.n477 87.5005
R2082 VSS.n803 VSS.n802 87.5005
R2083 VSS.n802 VSS.n493 87.5005
R2084 VSS.n499 VSS.n493 87.5005
R2085 VSS.n574 VSS.n499 87.5005
R2086 VSS.n578 VSS.n574 87.5005
R2087 VSS.n879 VSS.n330 87.5005
R2088 VSS.n882 VSS.n881 87.5005
R2089 VSS.n886 VSS.n327 87.5005
R2090 VSS.n889 VSS.n888 87.5005
R2091 VSS.n907 VSS.n270 77.0005
R2092 VSS.n905 VSS.n904 72.8296
R2093 VSS.n418 VSS.n411 68.2505
R2094 VSS.n1030 VSS.n62 68.2505
R2095 VSS.n173 VSS.n120 68.2505
R2096 VSS.n579 VSS.n578 68.2505
R2097 VSS.n875 VSS.n322 68.2505
R2098 VSS.t123 VSS.t229 65.5467
R2099 VSS.t83 VSS.n312 65.5467
R2100 VSS.n113 VSS.t245 65.5467
R2101 VSS.t82 VSS.n97 65.5467
R2102 VSS.t365 VSS.t339 65.5467
R2103 VSS.n913 VSS.n265 65.0005
R2104 VSS.t216 VSS.n896 63.726
R2105 VSS.n1029 VSS.t341 63.726
R2106 VSS.n956 VSS.n235 60.8596
R2107 VSS.n836 VSS.t18 60.0845
R2108 VSS.n289 VSS.n283 59.5005
R2109 VSS.n680 VSS.n475 59.5005
R2110 VSS.n963 VSS.n137 59.5005
R2111 VSS.n745 VSS.n528 59.5005
R2112 VSS.n701 VSS.n700 59.5005
R2113 VSS.t148 VSS.n314 56.4431
R2114 VSS.n996 VSS.t154 56.4431
R2115 VSS.t110 VSS.n1022 56.4431
R2116 VSS.n931 VSS.t247 55.2129
R2117 VSS.n932 VSS.t239 55.2129
R2118 VSS.t218 VSS.n937 55.2129
R2119 VSS.n936 VSS.t219 55.2129
R2120 VSS.n934 VSS.t244 55.2129
R2121 VSS.t367 VSS.n243 55.2129
R2122 VSS.n944 VSS.t284 55.2129
R2123 VSS.n945 VSS.t246 55.2129
R2124 VSS.n947 VSS.t240 55.2129
R2125 VSS.n948 VSS.t335 55.2129
R2126 VSS.n242 VSS.t285 55.2129
R2127 VSS.t286 VSS.n236 55.2129
R2128 VSS.t248 VSS.n235 55.2129
R2129 VSS.n419 VSS.t243 55.2129
R2130 VSS.n966 VSS.n131 54.6223
R2131 VSS.n972 VSS.n131 54.6223
R2132 VSS.n973 VSS.n972 54.6223
R2133 VSS.n208 VSS.t139 54.6223
R2134 VSS.n929 VSS.n248 52.5005
R2135 VSS.n938 VSS.n248 52.5005
R2136 VSS.n938 VSS.n245 52.5005
R2137 VSS.n942 VSS.n245 52.5005
R2138 VSS.n942 VSS.n244 52.5005
R2139 VSS.n244 VSS.n241 52.5005
R2140 VSS.n950 VSS.n241 52.5005
R2141 VSS.n950 VSS.n238 52.5005
R2142 VSS.n954 VSS.n238 52.5005
R2143 VSS.n954 VSS.n237 52.5005
R2144 VSS.n418 VSS.n237 52.5005
R2145 VSS.n289 VSS.n287 52.5005
R2146 VSS.n287 VSS.n286 52.5005
R2147 VSS.n286 VSS.n262 52.5005
R2148 VSS.n917 VSS.n262 52.5005
R2149 VSS.n917 VSS.n260 52.5005
R2150 VSS.n921 VSS.n260 52.5005
R2151 VSS.n924 VSS.n923 52.5005
R2152 VSS.n293 VSS.n283 52.5005
R2153 VSS.n293 VSS.n281 52.5005
R2154 VSS.n297 VSS.n281 52.5005
R2155 VSS.n297 VSS.n279 52.5005
R2156 VSS.n301 VSS.n279 52.5005
R2157 VSS.n301 VSS.n277 52.5005
R2158 VSS.n305 VSS.n277 52.5005
R2159 VSS.n305 VSS.n275 52.5005
R2160 VSS.n309 VSS.n275 52.5005
R2161 VSS.n309 VSS.n273 52.5005
R2162 VSS.n907 VSS.n273 52.5005
R2163 VSS.n911 VSS.n270 52.5005
R2164 VSS.n911 VSS.n269 52.5005
R2165 VSS.n469 VSS.n269 52.5005
R2166 VSS.n469 VSS.n402 52.5005
R2167 VSS.n465 VSS.n404 52.5005
R2168 VSS.n414 VSS.n413 52.5005
R2169 VSS.n461 VSS.n406 52.5005
R2170 VSS.n461 VSS.n405 52.5005
R2171 VSS.n457 VSS.n408 52.5005
R2172 VSS.n446 VSS.n445 52.5005
R2173 VSS.n450 VSS.n449 52.5005
R2174 VSS.n859 VSS.n400 52.5005
R2175 VSS.n849 VSS.n473 52.5005
R2176 VSS.n843 VSS.n842 52.5005
R2177 VSS.n839 VSS.n838 52.5005
R2178 VSS.n684 VSS.n680 52.5005
R2179 VSS.n685 VSS.n684 52.5005
R2180 VSS.n688 VSS.n685 52.5005
R2181 VSS.n688 VSS.n520 52.5005
R2182 VSS.n692 VSS.n520 52.5005
R2183 VSS.n692 VSS.n555 52.5005
R2184 VSS.n674 VSS.n555 52.5005
R2185 VSS.n674 VSS.n557 52.5005
R2186 VSS.n615 VSS.n557 52.5005
R2187 VSS.n615 VSS.n612 52.5005
R2188 VSS.n436 VSS.n435 52.5005
R2189 VSS.n432 VSS.n431 52.5005
R2190 VSS.n428 VSS.n140 52.5005
R2191 VSS.n959 VSS.n136 52.5005
R2192 VSS.n743 VSS.n742 52.5005
R2193 VSS.n740 VSS.n531 52.5005
R2194 VSS.n736 VSS.n734 52.5005
R2195 VSS.n759 VSS.n758 52.5005
R2196 VSS.n763 VSS.n525 52.5005
R2197 VSS.n766 VSS.n765 52.5005
R2198 VSS.n712 VSS.n543 52.5005
R2199 VSS.n715 VSS.n714 52.5005
R2200 VSS.n719 VSS.n718 52.5005
R2201 VSS.n781 VSS.n780 52.5005
R2202 VSS.n785 VSS.n509 52.5005
R2203 VSS.n788 VSS.n787 52.5005
R2204 VSS.n694 VSS.n550 52.5005
R2205 VSS.n698 VSS.n550 52.5005
R2206 VSS.n698 VSS.n549 52.5005
R2207 VSS.n617 VSS.n549 52.5005
R2208 VSS.n617 VSS.n134 52.5005
R2209 VSS.n967 VSS.n134 52.5005
R2210 VSS.n967 VSS.n132 52.5005
R2211 VSS.n971 VSS.n132 52.5005
R2212 VSS.n971 VSS.n126 52.5005
R2213 VSS.n983 VSS.n126 52.5005
R2214 VSS.n983 VSS.n123 52.5005
R2215 VSS.n987 VSS.n123 52.5005
R2216 VSS.n987 VSS.n122 52.5005
R2217 VSS.n180 VSS.n122 52.5005
R2218 VSS.n207 VSS.n180 52.5005
R2219 VSS.n194 VSS.n185 52.5005
R2220 VSS.n198 VSS.n186 52.5005
R2221 VSS.n187 VSS.n182 52.5005
R2222 VSS.n202 VSS.n182 52.5005
R2223 VSS.n670 VSS.n554 52.5005
R2224 VSS.n670 VSS.n547 52.5005
R2225 VSS.n622 VSS.n547 52.5005
R2226 VSS.n622 VSS.n560 52.5005
R2227 VSS.n608 VSS.n560 52.5005
R2228 VSS.n608 VSS.n135 52.5005
R2229 VSS.n604 VSS.n135 52.5005
R2230 VSS.n604 VSS.n130 52.5005
R2231 VSS.n974 VSS.n130 52.5005
R2232 VSS.n974 VSS.n127 52.5005
R2233 VSS.n978 VSS.n127 52.5005
R2234 VSS.n978 VSS.n121 52.5005
R2235 VSS.n213 VSS.n121 52.5005
R2236 VSS.n213 VSS.n176 52.5005
R2237 VSS.n209 VSS.n176 52.5005
R2238 VSS.n653 VSS.n629 52.5005
R2239 VSS.n657 VSS.n656 52.5005
R2240 VSS.n661 VSS.n650 52.5005
R2241 VSS.n649 VSS.n553 52.5005
R2242 VSS.n828 VSS.t237 50.9809
R2243 VSS.n230 VSS.t180 50.9809
R2244 VSS.n914 VSS.t98 50.7817
R2245 VSS.n929 VSS.n250 50.7505
R2246 VSS.n864 VSS.n863 50.7505
R2247 VSS.n454 VSS.n426 50.7505
R2248 VSS.n209 VSS.n178 50.7505
R2249 VSS.n665 VSS.n554 50.7505
R2250 VSS.n1028 VSS.n65 50.7505
R2251 VSS.n990 VSS.n119 50.7505
R2252 VSS.n598 VSS.n567 50.7505
R2253 VSS.n895 VSS.n324 50.7505
R2254 VSS.n956 VSS.n955 47.0565
R2255 VSS.n732 VSS.n533 42.0005
R2256 VSS.n772 VSS.n517 42.0005
R2257 VSS.n721 VSS.n538 42.0005
R2258 VSS.n778 VSS.n512 42.0005
R2259 VSS.n207 VSS.n179 42.0005
R2260 VSS.n694 VSS.n553 42.0005
R2261 VSS.n896 VSS.n323 41.8773
R2262 VSS.n489 VSS.t69 41.8773
R2263 VSS.n806 VSS.t209 41.8773
R2264 VSS.t34 VSS.n1004 41.8773
R2265 VSS.n1014 VSS.t106 41.8773
R2266 VSS.n1029 VSS.n64 41.8773
R2267 VSS.n687 VSS.n686 39.9818
R2268 VSS.n470 VSS.n401 39.1571
R2269 VSS.t293 VSS.t190 36.4151
R2270 VSS.t27 VSS.t300 36.4151
R2271 VSS.t84 VSS.t356 36.4151
R2272 VSS.t310 VSS.t360 36.4151
R2273 VSS.n454 VSS.n427 35.0005
R2274 VSS.n612 VSS.n137 35.0005
R2275 VSS.n770 VSS.n502 35.0005
R2276 VSS.n643 VSS.n502 35.0005
R2277 VSS.n643 VSS.n535 35.0005
R2278 VSS.n728 VSS.n535 35.0005
R2279 VSS.n728 VSS.n533 35.0005
R2280 VSS.n772 VSS.n501 35.0005
R2281 VSS.n641 VSS.n501 35.0005
R2282 VSS.n641 VSS.n637 35.0005
R2283 VSS.n637 VSS.n537 35.0005
R2284 VSS.n537 VSS.n528 35.0005
R2285 VSS.n794 VSS.n504 35.0005
R2286 VSS.n794 VSS.n503 35.0005
R2287 VSS.n539 VSS.n503 35.0005
R2288 VSS.n726 VSS.n539 35.0005
R2289 VSS.n726 VSS.n538 35.0005
R2290 VSS.n512 VSS.n500 35.0005
R2291 VSS.n630 VSS.n500 35.0005
R2292 VSS.n635 VSS.n630 35.0005
R2293 VSS.n635 VSS.n536 35.0005
R2294 VSS.n700 VSS.n536 35.0005
R2295 VSS.t235 VSS.n827 32.7736
R2296 VSS.n1012 VSS.t182 32.7736
R2297 VSS.n483 VSS.n332 29.6637
R2298 VSS.n1005 VSS.n59 29.6637
R2299 VSS.t127 VSS.n828 29.1322
R2300 VSS.n487 VSS.n332 28.4005
R2301 VSS.n1013 VSS.n59 28.4005
R2302 VSS.n231 VSS.t206 28.2218
R2303 VSS.n678 VSS.n495 26.5019
R2304 VSS.n154 VSS.n119 26.2505
R2305 VSS.n891 VSS.n324 26.2505
R2306 VSS.t247 VSS.t33 25.097
R2307 VSS.t33 VSS.t239 25.097
R2308 VSS.t249 VSS.t218 25.097
R2309 VSS.t249 VSS.t219 25.097
R2310 VSS.t244 VSS.t145 25.097
R2311 VSS.t145 VSS.t367 25.097
R2312 VSS.t38 VSS.t284 25.097
R2313 VSS.t38 VSS.t246 25.097
R2314 VSS.t240 VSS.t64 25.097
R2315 VSS.t64 VSS.t335 25.097
R2316 VSS.t285 VSS.t112 25.097
R2317 VSS.t112 VSS.t286 25.097
R2318 VSS.t158 VSS.t248 25.097
R2319 VSS.t243 VSS.t158 25.097
R2320 VSS.n770 VSS.n521 24.5005
R2321 VSS.n790 VSS.n504 24.5005
R2322 VSS.t70 VSS.n487 23.67
R2323 VSS.t208 VSS.n483 23.67
R2324 VSS.n771 VSS.n507 23.67
R2325 VSS.n973 VSS.t290 23.67
R2326 VSS.n1005 VSS.t35 23.67
R2327 VSS.t105 VSS.n1013 23.67
R2328 VSS.n861 VSS.n470 23.4945
R2329 VSS.n667 VSS.n395 21.3764
R2330 VSS.n1035 VSS.n1034 21.353
R2331 VSS.n873 VSS.n872 21.0663
R2332 VSS.n1033 VSS.n1032 21.0663
R2333 VSS.n965 VSS.t274 20.0285
R2334 VSS.n867 VSS.n866 19.8504
R2335 VSS.n913 VSS.n267 19.5788
R2336 VSS.n374 VSS.n373 19.4957
R2337 VSS.n42 VSS.n41 19.4957
R2338 VSS.n927 VSS.n257 19.4846
R2339 VSS.n351 VSS.n350 19.3062
R2340 VSS.n19 VSS.n18 19.3062
R2341 VSS.n776 VSS.n775 19.1783
R2342 VSS.n775 VSS.n774 18.8227
R2343 VSS.n338 VSS.n337 18.4989
R2344 VSS.n6 VSS.n5 18.4989
R2345 VSS.n905 VSS.n312 18.2078
R2346 VSS.n827 VSS.n487 18.2078
R2347 VSS.n829 VSS.n483 18.2078
R2348 VSS.n679 VSS.n476 18.2078
R2349 VSS.n801 VSS.n495 18.2078
R2350 VSS.n1006 VSS.n1005 18.2078
R2351 VSS.n1013 VSS.n1012 18.2078
R2352 VSS.n344 VSS.n338 16.9831
R2353 VSS.n347 VSS.n346 16.9831
R2354 VSS.n381 VSS.n375 16.9831
R2355 VSS.n384 VSS.n383 16.9831
R2356 VSS.n390 VSS.n389 16.9831
R2357 VSS.n58 VSS.n57 16.9831
R2358 VSS.n52 VSS.n51 16.9831
R2359 VSS.n50 VSS.n43 16.9831
R2360 VSS.n15 VSS.n14 16.9831
R2361 VSS.n13 VSS.n6 16.9831
R2362 VSS.n981 VSS.t291 16.5691
R2363 VSS.n621 VSS.t312 16.3871
R2364 VSS.n979 VSS.t322 16.3871
R2365 VSS.n988 VSS.t314 16.3871
R2366 VSS.n687 VSS.n507 16.3123
R2367 VSS.n367 VSS.n366 15.8092
R2368 VSS.n35 VSS.n34 15.8092
R2369 VSS.n251 VSS.t1 15.202
R2370 VSS.n957 VSS.n956 15.1168
R2371 VSS.t241 VSS.t269 14.5663
R2372 VSS.t270 VSS.t220 14.5663
R2373 VSS.t309 VSS.t280 14.5663
R2374 VSS.n251 VSS.t109 14.302
R2375 VSS.n252 VSS.t287 14.302
R2376 VSS.n253 VSS.t32 14.302
R2377 VSS.n254 VSS.t302 14.302
R2378 VSS.n255 VSS.t305 14.302
R2379 VSS.n256 VSS.t67 14.302
R2380 VSS.n193 VSS.n192 13.5139
R2381 VSS.n628 VSS.n627 13.5139
R2382 VSS.t306 VSS.n546 12.5635
R2383 VSS.t283 VSS.n603 11.6532
R2384 VSS.t103 VSS.n216 11.1069
R2385 VSS.n829 VSS.t135 10.9249
R2386 VSS.t210 VSS.t307 10.9249
R2387 VSS.t268 VSS.t72 10.9249
R2388 VSS.t271 VSS.t107 10.9249
R2389 VSS.t308 VSS.t37 10.9249
R2390 VSS.n208 VSS.t125 10.9249
R2391 VSS.n1006 VSS.t194 10.9249
R2392 VSS.n703 VSS.n513 10.2705
R2393 VSS.n709 VSS.n708 10.2705
R2394 VSS.n754 VSS.n753 10.2705
R2395 VSS.n748 VSS.n747 10.2705
R2396 VSS.n369 VSS.n368 9.98011
R2397 VSS.n37 VSS.n36 9.98011
R2398 VSS.n645 VSS.t260 9.28621
R2399 VSS.n673 VSS.t363 9.10414
R2400 VSS.t221 VSS.n699 9.10414
R2401 VSS.n618 VSS.t80 9.10414
R2402 VSS.n982 VSS.t220 9.10414
R2403 VSS.t280 VSS.n214 9.10414
R2404 VSS.n362 VSS.n352 8.57007
R2405 VSS.n370 VSS.n369 8.57007
R2406 VSS.n27 VSS.n20 8.57007
R2407 VSS.n38 VSS.n37 8.57007
R2408 VSS.n679 VSS.n678 8.29465
R2409 VSS.n871 VSS.n870 7.7855
R2410 VSS.n494 VSS.t304 7.32154
R2411 VSS.t368 VSS.n687 7.32154
R2412 VSS.t214 VSS.t216 7.28341
R2413 VSS.t212 VSS.t214 7.28341
R2414 VSS.t233 VSS.t212 7.28341
R2415 VSS.t229 VSS.t231 7.28341
R2416 VSS.t121 VSS.t123 7.28341
R2417 VSS.t119 VSS.t121 7.28341
R2418 VSS.t188 VSS.t186 7.28341
R2419 VSS.t186 VSS.t184 7.28341
R2420 VSS.t184 VSS.t150 7.28341
R2421 VSS.t150 VSS.t148 7.28341
R2422 VSS.t41 VSS.t83 7.28341
R2423 VSS.t277 VSS.t41 7.28341
R2424 VSS.t228 VSS.t277 7.28341
R2425 VSS.t16 VSS.t42 7.28341
R2426 VSS.t190 VSS.t278 7.28341
R2427 VSS.t350 VSS.t293 7.28341
R2428 VSS.t349 VSS.t350 7.28341
R2429 VSS.t69 VSS.t70 7.28341
R2430 VSS.t237 VSS.t235 7.28341
R2431 VSS.t5 VSS.t127 7.28341
R2432 VSS.t7 VSS.t5 7.28341
R2433 VSS.t11 VSS.t7 7.28341
R2434 VSS.t9 VSS.t11 7.28341
R2435 VSS.t13 VSS.t9 7.28341
R2436 VSS.t3 VSS.t13 7.28341
R2437 VSS.t135 VSS.t3 7.28341
R2438 VSS.t209 VSS.t208 7.28341
R2439 VSS.t62 VSS.t336 7.28341
R2440 VSS.t336 VSS.t27 7.28341
R2441 VSS.t300 VSS.t298 7.28341
R2442 VSS.t44 VSS.t362 7.28341
R2443 VSS.t43 VSS.t91 7.28341
R2444 VSS.t17 VSS.t43 7.28341
R2445 VSS.t18 VSS.t17 7.28341
R2446 VSS.t96 VSS.t113 7.28341
R2447 VSS.t258 VSS.t260 7.28341
R2448 VSS.t256 VSS.t258 7.28341
R2449 VSS.t312 VSS.t318 7.28341
R2450 VSS.t80 VSS.t320 7.28341
R2451 VSS.t290 VSS.t291 7.28341
R2452 VSS.t107 VSS.t108 7.28341
R2453 VSS.t324 VSS.t326 7.28341
R2454 VSS.t326 VSS.t314 7.28341
R2455 VSS.t143 VSS.t99 7.28341
R2456 VSS.t139 VSS.t141 7.28341
R2457 VSS.t60 VSS.t125 7.28341
R2458 VSS.t23 VSS.t56 7.28341
R2459 VSS.t21 VSS.t23 7.28341
R2460 VSS.t19 VSS.t21 7.28341
R2461 VSS.t154 VSS.t19 7.28341
R2462 VSS.t245 VSS.t87 7.28341
R2463 VSS.t87 VSS.t2 7.28341
R2464 VSS.t2 VSS.t63 7.28341
R2465 VSS.t281 VSS.t81 7.28341
R2466 VSS.t356 VSS.t351 7.28341
R2467 VSS.t153 VSS.t84 7.28341
R2468 VSS.t152 VSS.t153 7.28341
R2469 VSS.t35 VSS.t34 7.28341
R2470 VSS.t196 VSS.t194 7.28341
R2471 VSS.t198 VSS.t196 7.28341
R2472 VSS.t200 VSS.t198 7.28341
R2473 VSS.t192 VSS.t200 7.28341
R2474 VSS.t202 VSS.t192 7.28341
R2475 VSS.t204 VSS.t202 7.28341
R2476 VSS.t206 VSS.t204 7.28341
R2477 VSS.t180 VSS.t182 7.28341
R2478 VSS.t106 VSS.t105 7.28341
R2479 VSS.t361 VSS.t355 7.28341
R2480 VSS.t360 VSS.t361 7.28341
R2481 VSS.t47 VSS.t310 7.28341
R2482 VSS.t39 VSS.t292 7.28341
R2483 VSS.t177 VSS.t89 7.28341
R2484 VSS.t89 VSS.t179 7.28341
R2485 VSS.t179 VSS.t82 7.28341
R2486 VSS.t332 VSS.t110 7.28341
R2487 VSS.t330 VSS.t332 7.28341
R2488 VSS.t328 VSS.t330 7.28341
R2489 VSS.t226 VSS.t328 7.28341
R2490 VSS.t224 VSS.t222 7.28341
R2491 VSS.t222 VSS.t365 7.28341
R2492 VSS.t339 VSS.t337 7.28341
R2493 VSS.t347 VSS.t345 7.28341
R2494 VSS.t345 VSS.t343 7.28341
R2495 VSS.t343 VSS.t341 7.28341
R2496 VSS.n645 VSS.n644 7.10134
R2497 VSS.n699 VSS.n548 7.10134
R2498 VSS.n610 VSS.n609 7.10134
R2499 VSS.n982 VSS.n981 7.10134
R2500 VSS.n216 VSS.n214 7.10134
R2501 VSS.n853 VSS.t171 6.57557
R2502 VSS.t241 VSS.n601 6.55512
R2503 VSS.n707 VSS.n704 6.5388
R2504 VSS.n706 VSS.n705 6.5388
R2505 VSS.n750 VSS.n749 6.5388
R2506 VSS.n752 VSS.n751 6.5388
R2507 VSS.n847 VSS.n845 6.49615
R2508 VSS.n441 VSS.t175 6.45713
R2509 VSS.n440 VSS.n439 6.41078
R2510 VSS.n192 VSS.n190 6.38826
R2511 VSS.n627 VSS.n626 6.38826
R2512 VSS.n192 VSS.n191 6.38502
R2513 VSS.n627 VSS.n625 6.38502
R2514 VSS.n847 VSS.n846 6.31615
R2515 VSS.n853 VSS.n852 6.29483
R2516 VSS.n440 VSS.n438 6.29483
R2517 VSS.n855 VSS.n854 6.29333
R2518 VSS.n848 VSS.n847 6.278
R2519 VSS.n375 VSS.n374 6.20576
R2520 VSS.n43 VSS.n42 6.20576
R2521 VSS.n518 VSS.t94 6.19098
R2522 VSS.n856 VSS.n855 5.6555
R2523 VSS.t318 VSS.n620 5.64476
R2524 VSS.n619 VSS.t72 5.64476
R2525 VSS.n611 VSS.t268 5.64476
R2526 VSS.n980 VSS.t271 5.64476
R2527 VSS.n215 VSS.t308 5.64476
R2528 VSS.n442 VSS.n441 5.5955
R2529 VSS.n335 VSS.n333 5.57485
R2530 VSS.n341 VSS.n339 5.57485
R2531 VSS.n350 VSS.n348 5.57485
R2532 VSS.n355 VSS.n353 5.57485
R2533 VSS.n359 VSS.n357 5.57485
R2534 VSS.n378 VSS.n376 5.57485
R2535 VSS.n387 VSS.n385 5.57485
R2536 VSS.n373 VSS.n371 5.57485
R2537 VSS.n56 VSS.n54 5.57485
R2538 VSS.n47 VSS.n45 5.57485
R2539 VSS.n41 VSS.n39 5.57485
R2540 VSS.n25 VSS.n23 5.57485
R2541 VSS.n31 VSS.n29 5.57485
R2542 VSS.n10 VSS.n8 5.57485
R2543 VSS.n4 VSS.n2 5.57485
R2544 VSS.n18 VSS.n16 5.57485
R2545 VSS.n337 VSS.n336 5.48011
R2546 VSS.n361 VSS.n360 5.48011
R2547 VSS.n389 VSS.n388 5.48011
R2548 VSS.n57 VSS.n53 5.48011
R2549 VSS.n26 VSS.n22 5.48011
R2550 VSS.n5 VSS.n1 5.48011
R2551 VSS.n897 VSS.t233 5.46268
R2552 VSS.n898 VSS.t188 5.46268
R2553 VSS.t25 VSS.t16 5.46268
R2554 VSS.t65 VSS.t40 5.46268
R2555 VSS.t278 VSS.t55 5.46268
R2556 VSS.t298 VSS.t282 5.46268
R2557 VSS.t296 VSS.t73 5.46268
R2558 VSS.t294 VSS.t44 5.46268
R2559 VSS.n836 VSS.n476 5.46268
R2560 VSS.t94 VSS.t272 5.46268
R2561 VSS.n795 VSS.t92 5.46268
R2562 VSS.n663 VSS.t51 5.46268
R2563 VSS.t117 VSS.n693 5.46268
R2564 VSS.n644 VSS.t118 5.46268
R2565 VSS.n636 VSS.t256 5.46268
R2566 VSS.t303 VSS.t78 5.46268
R2567 VSS.t320 VSS.n600 5.46268
R2568 VSS.t71 VSS.n618 5.46268
R2569 VSS.t108 VSS.n979 5.46268
R2570 VSS.n171 VSS.t322 5.46268
R2571 VSS.t36 VSS.n988 5.46268
R2572 VSS.t275 VSS.t103 5.46268
R2573 VSS.t276 VSS.t101 5.46268
R2574 VSS.n217 VSS.t143 5.46268
R2575 VSS.n200 VSS.t60 5.46268
R2576 VSS.t56 VSS.n995 5.46268
R2577 VSS.t358 VSS.t281 5.46268
R2578 VSS.t353 VSS.t147 5.46268
R2579 VSS.t351 VSS.t90 5.46268
R2580 VSS.t157 VSS.t47 5.46268
R2581 VSS.t156 VSS.t45 5.46268
R2582 VSS.t292 VSS.t85 5.46268
R2583 VSS.n1023 VSS.t226 5.46268
R2584 VSS.n93 VSS.t347 5.46268
R2585 VSS.n335 VSS.n334 5.38537
R2586 VSS.n341 VSS.n340 5.38537
R2587 VSS.n343 VSS.n342 5.38537
R2588 VSS.n346 VSS.n345 5.38537
R2589 VSS.n350 VSS.n349 5.38537
R2590 VSS.n355 VSS.n354 5.38537
R2591 VSS.n364 VSS.n356 5.38537
R2592 VSS.n359 VSS.n358 5.38537
R2593 VSS.n366 VSS.n365 5.38537
R2594 VSS.n378 VSS.n377 5.38537
R2595 VSS.n380 VSS.n379 5.38537
R2596 VSS.n383 VSS.n382 5.38537
R2597 VSS.n387 VSS.n386 5.38537
R2598 VSS.n373 VSS.n372 5.38537
R2599 VSS.n56 VSS.n55 5.38537
R2600 VSS.n51 VSS.n44 5.38537
R2601 VSS.n49 VSS.n48 5.38537
R2602 VSS.n47 VSS.n46 5.38537
R2603 VSS.n41 VSS.n40 5.38537
R2604 VSS.n34 VSS.n21 5.38537
R2605 VSS.n25 VSS.n24 5.38537
R2606 VSS.n33 VSS.n32 5.38537
R2607 VSS.n31 VSS.n30 5.38537
R2608 VSS.n14 VSS.n7 5.38537
R2609 VSS.n12 VSS.n11 5.38537
R2610 VSS.n10 VSS.n9 5.38537
R2611 VSS.n4 VSS.n3 5.38537
R2612 VSS.n18 VSS.n17 5.38537
R2613 VSS.n646 VSS.t49 5.28061
R2614 VSS.n671 VSS.t28 5.28061
R2615 VSS.n926 VSS.n250 5.2005
R2616 VSS.n925 VSS.n924 5.2005
R2617 VSS.n923 VSS.n258 5.2005
R2618 VSS.n921 VSS.n920 5.2005
R2619 VSS.n263 VSS.n260 5.2005
R2620 VSS.n919 VSS.n260 5.2005
R2621 VSS.n917 VSS.n916 5.2005
R2622 VSS.n918 VSS.n917 5.2005
R2623 VSS.n264 VSS.n262 5.2005
R2624 VSS.n262 VSS.n261 5.2005
R2625 VSS.n286 VSS.n265 5.2005
R2626 VSS.n286 VSS.n285 5.2005
R2627 VSS.n287 VSS.n266 5.2005
R2628 VSS.n287 VSS.n284 5.2005
R2629 VSS.n289 VSS.n288 5.2005
R2630 VSS.n290 VSS.n289 5.2005
R2631 VSS.n907 VSS.n906 5.2005
R2632 VSS.n908 VSS.n907 5.2005
R2633 VSS.n311 VSS.n273 5.2005
R2634 VSS.n273 VSS.n272 5.2005
R2635 VSS.n310 VSS.n309 5.2005
R2636 VSS.n309 VSS.n308 5.2005
R2637 VSS.n275 VSS.n274 5.2005
R2638 VSS.n307 VSS.n275 5.2005
R2639 VSS.n305 VSS.n304 5.2005
R2640 VSS.n306 VSS.n305 5.2005
R2641 VSS.n303 VSS.n277 5.2005
R2642 VSS.n277 VSS.n276 5.2005
R2643 VSS.n302 VSS.n301 5.2005
R2644 VSS.n301 VSS.n300 5.2005
R2645 VSS.n279 VSS.n278 5.2005
R2646 VSS.n299 VSS.n279 5.2005
R2647 VSS.n297 VSS.n296 5.2005
R2648 VSS.n298 VSS.n297 5.2005
R2649 VSS.n295 VSS.n281 5.2005
R2650 VSS.n281 VSS.n280 5.2005
R2651 VSS.n294 VSS.n293 5.2005
R2652 VSS.n293 VSS.n292 5.2005
R2653 VSS.n283 VSS.n282 5.2005
R2654 VSS.n291 VSS.n283 5.2005
R2655 VSS.n416 VSS.n411 5.2005
R2656 VSS.n415 VSS.n414 5.2005
R2657 VSS.n413 VSS.n412 5.2005
R2658 VSS.n404 VSS.n403 5.2005
R2659 VSS.n466 VSS.n465 5.2005
R2660 VSS.n467 VSS.n402 5.2005
R2661 VSS.n470 VSS.n469 5.2005
R2662 VSS.n469 VSS.n468 5.2005
R2663 VSS.n269 VSS.n267 5.2005
R2664 VSS.n271 VSS.n269 5.2005
R2665 VSS.n912 VSS.n911 5.2005
R2666 VSS.n911 VSS.n910 5.2005
R2667 VSS.n270 VSS.n268 5.2005
R2668 VSS.n909 VSS.n270 5.2005
R2669 VSS.n930 VSS.n929 5.2005
R2670 VSS.n929 VSS.n928 5.2005
R2671 VSS.n933 VSS.n248 5.2005
R2672 VSS.n248 VSS.n247 5.2005
R2673 VSS.n938 VSS.t249 5.2005
R2674 VSS.n939 VSS.n938 5.2005
R2675 VSS.n935 VSS.n245 5.2005
R2676 VSS.n940 VSS.n245 5.2005
R2677 VSS.n943 VSS.n942 5.2005
R2678 VSS.n942 VSS.n941 5.2005
R2679 VSS.n244 VSS.t38 5.2005
R2680 VSS.n246 VSS.n244 5.2005
R2681 VSS.n946 VSS.n241 5.2005
R2682 VSS.n241 VSS.n240 5.2005
R2683 VSS.n950 VSS.n949 5.2005
R2684 VSS.n951 VSS.n950 5.2005
R2685 VSS.t112 VSS.n238 5.2005
R2686 VSS.n952 VSS.n238 5.2005
R2687 VSS.n955 VSS.n954 5.2005
R2688 VSS.n954 VSS.n953 5.2005
R2689 VSS.n420 VSS.n237 5.2005
R2690 VSS.n239 VSS.n237 5.2005
R2691 VSS.n418 VSS.n417 5.2005
R2692 VSS.n455 VSS.n454 5.2005
R2693 VSS.n454 VSS.n453 5.2005
R2694 VSS.n452 VSS.n427 5.2005
R2695 VSS.n451 VSS.n450 5.2005
R2696 VSS.n449 VSS.n448 5.2005
R2697 VSS.n447 VSS.n446 5.2005
R2698 VSS.n445 VSS.n444 5.2005
R2699 VSS.n408 VSS.n407 5.2005
R2700 VSS.n458 VSS.n457 5.2005
R2701 VSS.n459 VSS.n405 5.2005
R2702 VSS.n443 VSS.n426 5.2005
R2703 VSS.n437 VSS.n436 5.2005
R2704 VSS.n435 VSS.n434 5.2005
R2705 VSS.n433 VSS.n432 5.2005
R2706 VSS.n431 VSS.n430 5.2005
R2707 VSS.n429 VSS.n428 5.2005
R2708 VSS.n140 VSS.n139 5.2005
R2709 VSS.n960 VSS.n959 5.2005
R2710 VSS.n578 VSS.n577 5.2005
R2711 VSS.n578 VSS.n569 5.2005
R2712 VSS.n574 VSS.t303 5.2005
R2713 VSS.n574 VSS.n572 5.2005
R2714 VSS.n795 VSS.n499 5.2005
R2715 VSS.n571 VSS.n499 5.2005
R2716 VSS.t368 VSS.n493 5.2005
R2717 VSS.n570 VSS.n493 5.2005
R2718 VSS.n802 VSS.n801 5.2005
R2719 VSS.n802 VSS.n492 5.2005
R2720 VSS.n803 VSS.n476 5.2005
R2721 VSS.n804 VSS.n803 5.2005
R2722 VSS.n835 VSS.n477 5.2005
R2723 VSS.n805 VSS.n477 5.2005
R2724 VSS.n807 VSS.n806 5.2005
R2725 VSS.n808 VSS.n807 5.2005
R2726 VSS.n829 VSS.n484 5.2005
R2727 VSS.n809 VSS.n484 5.2005
R2728 VSS.n828 VSS.n485 5.2005
R2729 VSS.n810 VSS.n485 5.2005
R2730 VSS.n827 VSS.n486 5.2005
R2731 VSS.n811 VSS.n486 5.2005
R2732 VSS.n490 VSS.n489 5.2005
R2733 VSS.n812 VSS.n490 5.2005
R2734 VSS.n821 VSS.n820 5.2005
R2735 VSS.n820 VSS.n819 5.2005
R2736 VSS.n491 VSS.n312 5.2005
R2737 VSS.n818 VSS.n491 5.2005
R2738 VSS.n904 VSS.n313 5.2005
R2739 VSS.n817 VSS.n313 5.2005
R2740 VSS.n815 VSS.n314 5.2005
R2741 VSS.n816 VSS.n815 5.2005
R2742 VSS.n898 VSS.n320 5.2005
R2743 VSS.n814 VSS.n320 5.2005
R2744 VSS.n897 VSS.n321 5.2005
R2745 VSS.n813 VSS.n321 5.2005
R2746 VSS.n896 VSS.n322 5.2005
R2747 VSS.n331 VSS.n322 5.2005
R2748 VSS.n324 VSS.n323 5.2005
R2749 VSS.n893 VSS.n324 5.2005
R2750 VSS.n892 VSS.n891 5.2005
R2751 VSS.n889 VSS.n325 5.2005
R2752 VSS.n888 VSS.n326 5.2005
R2753 VSS.n886 VSS.n885 5.2005
R2754 VSS.n884 VSS.n327 5.2005
R2755 VSS.n883 VSS.n882 5.2005
R2756 VSS.n881 VSS.n328 5.2005
R2757 VSS.n879 VSS.n878 5.2005
R2758 VSS.n877 VSS.n330 5.2005
R2759 VSS.n876 VSS.n875 5.2005
R2760 VSS.n580 VSS.n579 5.2005
R2761 VSS.n582 VSS.n581 5.2005
R2762 VSS.n600 VSS.n564 5.2005
R2763 VSS.n583 VSS.n564 5.2005
R2764 VSS.n585 VSS.n584 5.2005
R2765 VSS.n587 VSS.n586 5.2005
R2766 VSS.n589 VSS.n588 5.2005
R2767 VSS.n591 VSS.n590 5.2005
R2768 VSS.n593 VSS.n592 5.2005
R2769 VSS.n595 VSS.n594 5.2005
R2770 VSS.n596 VSS.n566 5.2005
R2771 VSS.n598 VSS.n597 5.2005
R2772 VSS.n577 VSS.n567 5.2005
R2773 VSS.n568 VSS.n567 5.2005
R2774 VSS.t303 VSS.n498 5.2005
R2775 VSS.n498 VSS.n497 5.2005
R2776 VSS.n796 VSS.n795 5.2005
R2777 VSS.n797 VSS.n796 5.2005
R2778 VSS.t368 VSS.n496 5.2005
R2779 VSS.n798 VSS.n496 5.2005
R2780 VSS.n801 VSS.n800 5.2005
R2781 VSS.n800 VSS.n799 5.2005
R2782 VSS.n478 VSS.n476 5.2005
R2783 VSS.n480 VSS.n478 5.2005
R2784 VSS.n835 VSS.n834 5.2005
R2785 VSS.n834 VSS.n833 5.2005
R2786 VSS.n806 VSS.n479 5.2005
R2787 VSS.n832 VSS.n479 5.2005
R2788 VSS.n830 VSS.n829 5.2005
R2789 VSS.n831 VSS.n830 5.2005
R2790 VSS.n828 VSS.n482 5.2005
R2791 VSS.n482 VSS.n481 5.2005
R2792 VSS.n827 VSS.n826 5.2005
R2793 VSS.n826 VSS.n825 5.2005
R2794 VSS.n489 VSS.n488 5.2005
R2795 VSS.n824 VSS.n488 5.2005
R2796 VSS.n822 VSS.n821 5.2005
R2797 VSS.n823 VSS.n822 5.2005
R2798 VSS.n315 VSS.n312 5.2005
R2799 VSS.n317 VSS.n315 5.2005
R2800 VSS.n904 VSS.n903 5.2005
R2801 VSS.n903 VSS.n902 5.2005
R2802 VSS.n316 VSS.n314 5.2005
R2803 VSS.n901 VSS.n316 5.2005
R2804 VSS.n899 VSS.n898 5.2005
R2805 VSS.n900 VSS.n899 5.2005
R2806 VSS.n897 VSS.n319 5.2005
R2807 VSS.n319 VSS.n318 5.2005
R2808 VSS.n896 VSS.n895 5.2005
R2809 VSS.n895 VSS.n894 5.2005
R2810 VSS.n1030 VSS.n1029 5.2005
R2811 VSS.n1031 VSS.n1030 5.2005
R2812 VSS.n93 VSS.n63 5.2005
R2813 VSS.n63 VSS.n61 5.2005
R2814 VSS.n1023 VSS.n94 5.2005
R2815 VSS.n141 VSS.n94 5.2005
R2816 VSS.n1022 VSS.n95 5.2005
R2817 VSS.n142 VSS.n95 5.2005
R2818 VSS.n1021 VSS.n96 5.2005
R2819 VSS.n143 VSS.n96 5.2005
R2820 VSS.n144 VSS.n97 5.2005
R2821 VSS.n145 VSS.n144 5.2005
R2822 VSS.n1015 VSS.n101 5.2005
R2823 VSS.n146 VSS.n101 5.2005
R2824 VSS.n1014 VSS.n102 5.2005
R2825 VSS.n147 VSS.n102 5.2005
R2826 VSS.n1012 VSS.n103 5.2005
R2827 VSS.n148 VSS.n103 5.2005
R2828 VSS.n230 VSS.n229 5.2005
R2829 VSS.n229 VSS.n228 5.2005
R2830 VSS.n1006 VSS.n107 5.2005
R2831 VSS.n227 VSS.n107 5.2005
R2832 VSS.n1004 VSS.n108 5.2005
R2833 VSS.n226 VSS.n108 5.2005
R2834 VSS.n1003 VSS.n109 5.2005
R2835 VSS.n225 VSS.n109 5.2005
R2836 VSS.n223 VSS.n113 5.2005
R2837 VSS.n224 VSS.n223 5.2005
R2838 VSS.n997 VSS.n114 5.2005
R2839 VSS.n222 VSS.n114 5.2005
R2840 VSS.n996 VSS.n115 5.2005
R2841 VSS.n221 VSS.n115 5.2005
R2842 VSS.n995 VSS.n116 5.2005
R2843 VSS.n220 VSS.n116 5.2005
R2844 VSS.n218 VSS.n217 5.2005
R2845 VSS.n219 VSS.n218 5.2005
R2846 VSS.n989 VSS.n120 5.2005
R2847 VSS.n175 VSS.n120 5.2005
R2848 VSS.n171 VSS.n119 5.2005
R2849 VSS.n119 VSS.n118 5.2005
R2850 VSS.n156 VSS.n154 5.2005
R2851 VSS.n169 VSS.n168 5.2005
R2852 VSS.n167 VSS.n155 5.2005
R2853 VSS.n166 VSS.n165 5.2005
R2854 VSS.n164 VSS.n163 5.2005
R2855 VSS.n162 VSS.n161 5.2005
R2856 VSS.n160 VSS.n159 5.2005
R2857 VSS.n158 VSS.n157 5.2005
R2858 VSS.n150 VSS.n149 5.2005
R2859 VSS.n174 VSS.n173 5.2005
R2860 VSS.n64 VSS.n62 5.2005
R2861 VSS.n62 VSS.n60 5.2005
R2862 VSS.n74 VSS.n73 5.2005
R2863 VSS.n75 VSS.n71 5.2005
R2864 VSS.n77 VSS.n76 5.2005
R2865 VSS.n79 VSS.n69 5.2005
R2866 VSS.n81 VSS.n80 5.2005
R2867 VSS.n82 VSS.n68 5.2005
R2868 VSS.n84 VSS.n83 5.2005
R2869 VSS.n86 VSS.n67 5.2005
R2870 VSS.n89 VSS.n88 5.2005
R2871 VSS.n90 VSS.n65 5.2005
R2872 VSS.n1029 VSS.n1028 5.2005
R2873 VSS.n1028 VSS.n1027 5.2005
R2874 VSS.n93 VSS.n66 5.2005
R2875 VSS.n1026 VSS.n66 5.2005
R2876 VSS.n1024 VSS.n1023 5.2005
R2877 VSS.n1025 VSS.n1024 5.2005
R2878 VSS.n1022 VSS.n92 5.2005
R2879 VSS.n92 VSS.n91 5.2005
R2880 VSS.n1021 VSS.n1020 5.2005
R2881 VSS.n1020 VSS.n1019 5.2005
R2882 VSS.n98 VSS.n97 5.2005
R2883 VSS.n1018 VSS.n98 5.2005
R2884 VSS.n1016 VSS.n1015 5.2005
R2885 VSS.n1017 VSS.n1016 5.2005
R2886 VSS.n1014 VSS.n100 5.2005
R2887 VSS.n100 VSS.n99 5.2005
R2888 VSS.n1012 VSS.n1011 5.2005
R2889 VSS.n1011 VSS.n1010 5.2005
R2890 VSS.n230 VSS.n104 5.2005
R2891 VSS.n1009 VSS.n104 5.2005
R2892 VSS.n1007 VSS.n1006 5.2005
R2893 VSS.n1008 VSS.n1007 5.2005
R2894 VSS.n1004 VSS.n106 5.2005
R2895 VSS.n106 VSS.n105 5.2005
R2896 VSS.n1003 VSS.n1002 5.2005
R2897 VSS.n1002 VSS.n1001 5.2005
R2898 VSS.n113 VSS.n110 5.2005
R2899 VSS.n1000 VSS.n110 5.2005
R2900 VSS.n998 VSS.n997 5.2005
R2901 VSS.n999 VSS.n998 5.2005
R2902 VSS.n996 VSS.n112 5.2005
R2903 VSS.n112 VSS.n111 5.2005
R2904 VSS.n995 VSS.n994 5.2005
R2905 VSS.n994 VSS.n993 5.2005
R2906 VSS.n217 VSS.n117 5.2005
R2907 VSS.n992 VSS.n117 5.2005
R2908 VSS.n990 VSS.n989 5.2005
R2909 VSS.n991 VSS.n990 5.2005
R2910 VSS.n209 VSS.n208 5.2005
R2911 VSS.n210 VSS.n209 5.2005
R2912 VSS.t139 VSS.n176 5.2005
R2913 VSS.n211 VSS.n176 5.2005
R2914 VSS.n214 VSS.n213 5.2005
R2915 VSS.n213 VSS.n212 5.2005
R2916 VSS.n988 VSS.n121 5.2005
R2917 VSS.n128 VSS.n121 5.2005
R2918 VSS.n979 VSS.n978 5.2005
R2919 VSS.n978 VSS.n977 5.2005
R2920 VSS.n982 VSS.n127 5.2005
R2921 VSS.n976 VSS.n127 5.2005
R2922 VSS.n974 VSS.n973 5.2005
R2923 VSS.n975 VSS.n974 5.2005
R2924 VSS.n972 VSS.n130 5.2005
R2925 VSS.n130 VSS.n129 5.2005
R2926 VSS.n604 VSS.n131 5.2005
R2927 VSS.n605 VSS.n604 5.2005
R2928 VSS.n966 VSS.n135 5.2005
R2929 VSS.n606 VSS.n135 5.2005
R2930 VSS.n609 VSS.n608 5.2005
R2931 VSS.n608 VSS.n607 5.2005
R2932 VSS.n618 VSS.n560 5.2005
R2933 VSS.n560 VSS.n559 5.2005
R2934 VSS.n622 VSS.n621 5.2005
R2935 VSS.n623 VSS.n622 5.2005
R2936 VSS.n699 VSS.n547 5.2005
R2937 VSS.n624 VSS.n547 5.2005
R2938 VSS.t30 VSS.n670 5.2005
R2939 VSS.n670 VSS.n669 5.2005
R2940 VSS.t68 VSS.n554 5.2005
R2941 VSS.n668 VSS.n554 5.2005
R2942 VSS.n663 VSS.n553 5.2005
R2943 VSS.n553 VSS.n552 5.2005
R2944 VSS.n651 VSS.n649 5.2005
R2945 VSS.n661 VSS.n660 5.2005
R2946 VSS.n659 VSS.n650 5.2005
R2947 VSS.n658 VSS.n657 5.2005
R2948 VSS.n656 VSS.n655 5.2005
R2949 VSS.n654 VSS.n653 5.2005
R2950 VSS.n652 VSS.n629 5.2005
R2951 VSS.n666 VSS.n665 5.2005
R2952 VSS.n178 VSS.n177 5.2005
R2953 VSS.n195 VSS.n194 5.2005
R2954 VSS.n196 VSS.n185 5.2005
R2955 VSS.n198 VSS.n197 5.2005
R2956 VSS.n189 VSS.n186 5.2005
R2957 VSS.n188 VSS.n187 5.2005
R2958 VSS.n200 VSS.n182 5.2005
R2959 VSS.n182 VSS.n181 5.2005
R2960 VSS.n203 VSS.n202 5.2005
R2961 VSS.n204 VSS.n179 5.2005
R2962 VSS.n208 VSS.n207 5.2005
R2963 VSS.n207 VSS.n206 5.2005
R2964 VSS.n180 VSS.t139 5.2005
R2965 VSS.n205 VSS.n180 5.2005
R2966 VSS.n214 VSS.n122 5.2005
R2967 VSS.n124 VSS.n122 5.2005
R2968 VSS.n988 VSS.n987 5.2005
R2969 VSS.n987 VSS.n986 5.2005
R2970 VSS.n979 VSS.n123 5.2005
R2971 VSS.n985 VSS.n123 5.2005
R2972 VSS.n983 VSS.n982 5.2005
R2973 VSS.n984 VSS.n983 5.2005
R2974 VSS.n973 VSS.n126 5.2005
R2975 VSS.n126 VSS.n125 5.2005
R2976 VSS.n972 VSS.n971 5.2005
R2977 VSS.n971 VSS.n970 5.2005
R2978 VSS.n132 VSS.n131 5.2005
R2979 VSS.n969 VSS.n132 5.2005
R2980 VSS.n967 VSS.n966 5.2005
R2981 VSS.n968 VSS.n967 5.2005
R2982 VSS.n609 VSS.n134 5.2005
R2983 VSS.n134 VSS.n133 5.2005
R2984 VSS.n618 VSS.n617 5.2005
R2985 VSS.n617 VSS.n616 5.2005
R2986 VSS.n621 VSS.n549 5.2005
R2987 VSS.n551 VSS.n549 5.2005
R2988 VSS.n699 VSS.n698 5.2005
R2989 VSS.n698 VSS.n697 5.2005
R2990 VSS.t30 VSS.n550 5.2005
R2991 VSS.n696 VSS.n550 5.2005
R2992 VSS.n694 VSS.t68 5.2005
R2993 VSS.n695 VSS.n694 5.2005
R2994 VSS.n700 VSS.t221 5.2005
R2995 VSS.n700 VSS.n544 5.2005
R2996 VSS.n727 VSS.n536 5.2005
R2997 VSS.n631 VSS.n536 5.2005
R2998 VSS.n636 VSS.n635 5.2005
R2999 VSS.n635 VSS.n634 5.2005
R3000 VSS.n644 VSS.n630 5.2005
R3001 VSS.n633 VSS.n630 5.2005
R3002 VSS.n795 VSS.n500 5.2005
R3003 VSS.n632 VSS.n500 5.2005
R3004 VSS.n771 VSS.n512 5.2005
R3005 VSS.n514 VSS.n512 5.2005
R3006 VSS.n791 VSS.n790 5.2005
R3007 VSS.n788 VSS.n506 5.2005
R3008 VSS.n787 VSS.n508 5.2005
R3009 VSS.n785 VSS.n784 5.2005
R3010 VSS.n783 VSS.n509 5.2005
R3011 VSS.n782 VSS.n781 5.2005
R3012 VSS.n780 VSS.n510 5.2005
R3013 VSS.n778 VSS.n777 5.2005
R3014 VSS.n702 VSS.n701 5.2005
R3015 VSS.n710 VSS.n543 5.2005
R3016 VSS.n712 VSS.n711 5.2005
R3017 VSS.n714 VSS.n542 5.2005
R3018 VSS.n716 VSS.n715 5.2005
R3019 VSS.n718 VSS.n717 5.2005
R3020 VSS.n719 VSS.n540 5.2005
R3021 VSS.n722 VSS.n721 5.2005
R3022 VSS.t221 VSS.n538 5.2005
R3023 VSS.n723 VSS.n538 5.2005
R3024 VSS.n727 VSS.n726 5.2005
R3025 VSS.n726 VSS.n725 5.2005
R3026 VSS.n636 VSS.n539 5.2005
R3027 VSS.n724 VSS.n539 5.2005
R3028 VSS.n644 VSS.n503 5.2005
R3029 VSS.n505 VSS.n503 5.2005
R3030 VSS.n795 VSS.n794 5.2005
R3031 VSS.n794 VSS.n793 5.2005
R3032 VSS.n771 VSS.n504 5.2005
R3033 VSS.n792 VSS.n504 5.2005
R3034 VSS.t221 VSS.n528 5.2005
R3035 VSS.n528 VSS.n527 5.2005
R3036 VSS.n727 VSS.n537 5.2005
R3037 VSS.n638 VSS.n537 5.2005
R3038 VSS.n637 VSS.n636 5.2005
R3039 VSS.n639 VSS.n637 5.2005
R3040 VSS.n644 VSS.n641 5.2005
R3041 VSS.n641 VSS.n640 5.2005
R3042 VSS.n795 VSS.n501 5.2005
R3043 VSS.n516 VSS.n501 5.2005
R3044 VSS.n772 VSS.n771 5.2005
R3045 VSS.n773 VSS.n772 5.2005
R3046 VSS.n768 VSS.n521 5.2005
R3047 VSS.n767 VSS.n766 5.2005
R3048 VSS.n765 VSS.n523 5.2005
R3049 VSS.n763 VSS.n762 5.2005
R3050 VSS.n761 VSS.n525 5.2005
R3051 VSS.n760 VSS.n759 5.2005
R3052 VSS.n758 VSS.n755 5.2005
R3053 VSS.n517 VSS.n515 5.2005
R3054 VSS.n746 VSS.n745 5.2005
R3055 VSS.n743 VSS.n526 5.2005
R3056 VSS.n742 VSS.n530 5.2005
R3057 VSS.n740 VSS.n739 5.2005
R3058 VSS.n738 VSS.n531 5.2005
R3059 VSS.n737 VSS.n736 5.2005
R3060 VSS.n734 VSS.n532 5.2005
R3061 VSS.n732 VSS.n731 5.2005
R3062 VSS.t221 VSS.n533 5.2005
R3063 VSS.n730 VSS.n533 5.2005
R3064 VSS.n728 VSS.n727 5.2005
R3065 VSS.n729 VSS.n728 5.2005
R3066 VSS.n636 VSS.n535 5.2005
R3067 VSS.n535 VSS.n534 5.2005
R3068 VSS.n644 VSS.n643 5.2005
R3069 VSS.n643 VSS.n642 5.2005
R3070 VSS.n795 VSS.n502 5.2005
R3071 VSS.n522 VSS.n502 5.2005
R3072 VSS.n771 VSS.n770 5.2005
R3073 VSS.n770 VSS.n769 5.2005
R3074 VSS.n681 VSS.n475 5.2005
R3075 VSS.n838 VSS.n474 5.2005
R3076 VSS.n961 VSS.n136 5.2005
R3077 VSS.n963 VSS.n962 5.2005
R3078 VSS.n602 VSS.n137 5.2005
R3079 VSS.n138 VSS.n137 5.2005
R3080 VSS.n612 VSS.t241 5.2005
R3081 VSS.n613 VSS.n612 5.2005
R3082 VSS.t80 VSS.n615 5.2005
R3083 VSS.n615 VSS.n614 5.2005
R3084 VSS.n577 VSS.n557 5.2005
R3085 VSS.n557 VSS.n556 5.2005
R3086 VSS.n674 VSS.n673 5.2005
R3087 VSS.n675 VSS.n674 5.2005
R3088 VSS.n636 VSS.n555 5.2005
R3089 VSS.n676 VSS.n555 5.2005
R3090 VSS.n693 VSS.n692 5.2005
R3091 VSS.n692 VSS.n691 5.2005
R3092 VSS.n771 VSS.n520 5.2005
R3093 VSS.n690 VSS.n520 5.2005
R3094 VSS.n688 VSS.t368 5.2005
R3095 VSS.n689 VSS.n688 5.2005
R3096 VSS.n686 VSS.n685 5.2005
R3097 VSS.n685 VSS.n677 5.2005
R3098 VSS.n684 VSS.n495 5.2005
R3099 VSS.n684 VSS.n683 5.2005
R3100 VSS.n680 VSS.n679 5.2005
R3101 VSS.n682 VSS.n680 5.2005
R3102 VSS.n840 VSS.n839 5.2005
R3103 VSS.n842 VSS.n841 5.2005
R3104 VSS.n844 VSS.n843 5.2005
R3105 VSS.n850 VSS.n849 5.2005
R3106 VSS.n851 VSS.n473 5.2005
R3107 VSS.n859 VSS.n858 5.2005
R3108 VSS.n857 VSS.n400 5.2005
R3109 VSS.n863 VSS.n397 5.2005
R3110 VSS.n462 VSS.n461 5.2005
R3111 VSS.n461 VSS.n460 5.2005
R3112 VSS.n406 VSS.n398 5.2005
R3113 VSS.n865 VSS.n864 5.2005
R3114 VSS.n678 VSS.t146 4.95782
R3115 VSS.t115 VSS.n519 4.73439
R3116 VSS.t262 VSS.n558 4.73439
R3117 VSS.n257 VSS.n256 4.7005
R3118 VSS.n891 VSS.n890 4.6486
R3119 VSS.n888 VSS.n887 4.6486
R3120 VSS.n329 VSS.n327 4.6486
R3121 VSS.n881 VSS.n880 4.6486
R3122 VSS.n874 VSS.n330 4.6486
R3123 VSS.n581 VSS.n563 4.6486
R3124 VSS.n587 VSS.n562 4.6486
R3125 VSS.n591 VSS.n561 4.6486
R3126 VSS.n592 VSS.n565 4.6486
R3127 VSS.n170 VSS.n154 4.6486
R3128 VSS.n155 VSS.n153 4.6486
R3129 VSS.n164 VSS.n152 4.6486
R3130 VSS.n160 VSS.n151 4.6486
R3131 VSS.n172 VSS.n150 4.6486
R3132 VSS.n72 VSS.n71 4.6486
R3133 VSS.n79 VSS.n78 4.6486
R3134 VSS.n70 VSS.n68 4.6486
R3135 VSS.n86 VSS.n85 4.6486
R3136 VSS.n73 VSS.n72 4.6486
R3137 VSS.n78 VSS.n77 4.6486
R3138 VSS.n80 VSS.n70 4.6486
R3139 VSS.n85 VSS.n84 4.6486
R3140 VSS.n173 VSS.n172 4.6486
R3141 VSS.n157 VSS.n151 4.6486
R3142 VSS.n161 VSS.n152 4.6486
R3143 VSS.n165 VSS.n153 4.6486
R3144 VSS.n170 VSS.n169 4.6486
R3145 VSS.n579 VSS.n563 4.6486
R3146 VSS.n584 VSS.n562 4.6486
R3147 VSS.n588 VSS.n561 4.6486
R3148 VSS.n594 VSS.n565 4.6486
R3149 VSS.n875 VSS.n874 4.6486
R3150 VSS.n880 VSS.n879 4.6486
R3151 VSS.n882 VSS.n329 4.6486
R3152 VSS.n887 VSS.n886 4.6486
R3153 VSS.n890 VSS.n889 4.6486
R3154 VSS.n869 VSS.n868 4.5005
R3155 VSS.n868 VSS.n396 4.5005
R3156 VSS.n869 VSS.n392 4.5005
R3157 VSS.n393 VSS.n392 4.5005
R3158 VSS.n706 VSS.n703 4.5005
R3159 VSS.n708 VSS.n707 4.5005
R3160 VSS.n753 VSS.n752 4.5005
R3161 VSS.n750 VSS.n748 4.5005
R3162 VSS.n394 VSS.n393 4.5005
R3163 VSS.n396 VSS.n394 4.5005
R3164 VSS.n872 VSS.n871 4.5005
R3165 VSS.n364 VSS.n363 4.5005
R3166 VSS.n362 VSS.n361 4.5005
R3167 VSS.n1034 VSS.n1033 4.5005
R3168 VSS.n33 VSS.n28 4.5005
R3169 VSS.n27 VSS.n26 4.5005
R3170 VSS.n872 VSS.n332 4.49787
R3171 VSS.n1033 VSS.n59 4.49787
R3172 VSS.n934 VSS.n243 4.48215
R3173 VSS.n945 VSS.n944 4.48215
R3174 VSS.n948 VSS.n947 4.48215
R3175 VSS.n242 VSS.n236 4.48215
R3176 VSS.n419 VSS.n235 4.48215
R3177 VSS.n259 VSS.n250 4.34122
R3178 VSS.n923 VSS.n922 4.34122
R3179 VSS.n411 VSS.n409 4.34122
R3180 VSS.n413 VSS.n410 4.34122
R3181 VSS.n465 VSS.n464 4.34122
R3182 VSS.n922 VSS.n921 4.34122
R3183 VSS.n924 VSS.n259 4.34122
R3184 VSS.n464 VSS.n402 4.34122
R3185 VSS.n410 VSS.n404 4.34122
R3186 VSS.n414 VSS.n409 4.34122
R3187 VSS.n427 VSS.n425 4.34122
R3188 VSS.n449 VSS.n424 4.34122
R3189 VSS.n445 VSS.n423 4.34122
R3190 VSS.n457 VSS.n456 4.34122
R3191 VSS.n426 VSS.n232 4.34122
R3192 VSS.n435 VSS.n233 4.34122
R3193 VSS.n431 VSS.n234 4.34122
R3194 VSS.n958 VSS.n140 4.34122
R3195 VSS.n662 VSS.n649 4.34122
R3196 VSS.n650 VSS.n648 4.34122
R3197 VSS.n656 VSS.n647 4.34122
R3198 VSS.n664 VSS.n629 4.34122
R3199 VSS.n184 VSS.n178 4.34122
R3200 VSS.n199 VSS.n198 4.34122
R3201 VSS.n186 VSS.n183 4.34122
R3202 VSS.n202 VSS.n201 4.34122
R3203 VSS.n790 VSS.n789 4.34122
R3204 VSS.n787 VSS.n786 4.34122
R3205 VSS.n511 VSS.n509 4.34122
R3206 VSS.n780 VSS.n779 4.34122
R3207 VSS.n545 VSS.n543 4.34122
R3208 VSS.n714 VSS.n713 4.34122
R3209 VSS.n715 VSS.n541 4.34122
R3210 VSS.n720 VSS.n719 4.34122
R3211 VSS.n524 VSS.n521 4.34122
R3212 VSS.n765 VSS.n764 4.34122
R3213 VSS.n756 VSS.n525 4.34122
R3214 VSS.n758 VSS.n757 4.34122
R3215 VSS.n745 VSS.n744 4.34122
R3216 VSS.n742 VSS.n741 4.34122
R3217 VSS.n735 VSS.n531 4.34122
R3218 VSS.n734 VSS.n733 4.34122
R3219 VSS.n837 VSS.n475 4.34122
R3220 VSS.n964 VSS.n136 4.34122
R3221 VSS.n839 VSS.n471 4.34122
R3222 VSS.n843 VSS.n472 4.34122
R3223 VSS.n860 VSS.n473 4.34122
R3224 VSS.n862 VSS.n400 4.34122
R3225 VSS.n406 VSS.n399 4.34122
R3226 VSS.n864 VSS.n399 4.34122
R3227 VSS.n456 VSS.n405 4.34122
R3228 VSS.n423 VSS.n408 4.34122
R3229 VSS.n446 VSS.n424 4.34122
R3230 VSS.n450 VSS.n425 4.34122
R3231 VSS.n863 VSS.n862 4.34122
R3232 VSS.n860 VSS.n859 4.34122
R3233 VSS.n849 VSS.n472 4.34122
R3234 VSS.n842 VSS.n471 4.34122
R3235 VSS.n838 VSS.n837 4.34122
R3236 VSS.n436 VSS.n232 4.34122
R3237 VSS.n432 VSS.n233 4.34122
R3238 VSS.n428 VSS.n234 4.34122
R3239 VSS.n959 VSS.n958 4.34122
R3240 VSS.n964 VSS.n963 4.34122
R3241 VSS.n744 VSS.n743 4.34122
R3242 VSS.n741 VSS.n740 4.34122
R3243 VSS.n736 VSS.n735 4.34122
R3244 VSS.n733 VSS.n732 4.34122
R3245 VSS.n757 VSS.n517 4.34122
R3246 VSS.n759 VSS.n756 4.34122
R3247 VSS.n764 VSS.n763 4.34122
R3248 VSS.n766 VSS.n524 4.34122
R3249 VSS.n701 VSS.n545 4.34122
R3250 VSS.n713 VSS.n712 4.34122
R3251 VSS.n718 VSS.n541 4.34122
R3252 VSS.n721 VSS.n720 4.34122
R3253 VSS.n779 VSS.n778 4.34122
R3254 VSS.n781 VSS.n511 4.34122
R3255 VSS.n786 VSS.n785 4.34122
R3256 VSS.n789 VSS.n788 4.34122
R3257 VSS.n194 VSS.n184 4.34122
R3258 VSS.n199 VSS.n185 4.34122
R3259 VSS.n187 VSS.n183 4.34122
R3260 VSS.n201 VSS.n179 4.34122
R3261 VSS.n665 VSS.n664 4.34122
R3262 VSS.n653 VSS.n647 4.34122
R3263 VSS.n657 VSS.n648 4.34122
R3264 VSS.n662 VSS.n661 4.34122
R3265 VSS.n603 VSS.n601 4.08867
R3266 VSS.n573 VSS.n558 4.08867
R3267 VSS.n519 VSS.n518 4.08867
R3268 VSS.n351 VSS.n347 3.83734
R3269 VSS.n19 VSS.n15 3.83734
R3270 VSS.n599 VSS.n566 3.72542
R3271 VSS.n88 VSS.n87 3.72542
R3272 VSS.n87 VSS.n65 3.72542
R3273 VSS.n599 VSS.n598 3.72542
R3274 VSS.n932 VSS.n931 3.6553
R3275 VSS.n937 VSS.n936 3.6553
R3276 VSS.n821 VSS.t228 3.64196
R3277 VSS.n821 VSS.t42 3.64196
R3278 VSS.n835 VSS.t362 3.64196
R3279 VSS.t91 VSS.n835 3.64196
R3280 VSS.t68 VSS.t117 3.64196
R3281 VSS.t68 VSS.t118 3.64196
R3282 VSS.t78 VSS.t242 3.64196
R3283 VSS.n727 VSS.t288 3.64196
R3284 VSS.t307 VSS.t137 3.64196
R3285 VSS.n577 VSS.t211 3.64196
R3286 VSS.n621 VSS.n529 3.64196
R3287 VSS.t273 VSS.n602 3.64196
R3288 VSS.n602 VSS.t274 3.64196
R3289 VSS.n966 VSS.n965 3.64196
R3290 VSS.n989 VSS.t36 3.64196
R3291 VSS.n989 VSS.t37 3.64196
R3292 VSS.n1003 VSS.t63 3.64196
R3293 VSS.t81 VSS.n1003 3.64196
R3294 VSS.n1015 VSS.t39 3.64196
R3295 VSS.n1015 VSS.t177 3.64196
R3296 VSS.n620 VSS.n619 3.63551
R3297 VSS.n576 VSS.n546 3.63551
R3298 VSS.n801 VSS.n494 3.56721
R3299 VSS.n686 VSS.n494 3.56721
R3300 VSS.n216 VSS.n215 3.54389
R3301 VSS.n981 VSS.n980 3.54389
R3302 VSS.n611 VSS.n610 3.54389
R3303 VSS.n575 VSS.n548 3.54389
R3304 VSS.n672 VSS.t289 3.45988
R3305 VSS.n352 VSS.n351 3.43471
R3306 VSS.n20 VSS.n19 3.43471
R3307 VSS.n257 VSS.n0 3.2405
R3308 VSS.n603 VSS.t273 2.91367
R3309 VSS.n870 VSS.n869 2.80513
R3310 VSS.n363 VSS.n362 2.73963
R3311 VSS.n28 VSS.n27 2.73963
R3312 VSS.n870 VSS.n0 2.633
R3313 VSS.n519 VSS.t113 2.54952
R3314 VSS.t30 VSS.n558 2.54952
R3315 VSS.t242 VSS.n573 2.54952
R3316 VSS.n609 VSS.n601 2.54952
R3317 VSS.n869 VSS.n394 2.29365
R3318 VSS.t51 VSS.n646 2.0033
R3319 VSS.n671 VSS.t30 2.0033
R3320 VSS.t363 VSS.n672 2.0033
R3321 VSS.n673 VSS.n548 2.0033
R3322 VSS.t221 VSS.n546 2.0033
R3323 VSS.t137 VSS.n575 2.0033
R3324 VSS.n577 VSS.n576 2.0033
R3325 VSS.n610 VSS.t283 2.0033
R3326 VSS.t231 VSS.n897 1.82123
R3327 VSS.n898 VSS.t119 1.82123
R3328 VSS.t40 VSS.t25 1.82123
R3329 VSS.t55 VSS.t65 1.82123
R3330 VSS.n489 VSS.t349 1.82123
R3331 VSS.n806 VSS.t62 1.82123
R3332 VSS.t282 VSS.t296 1.82123
R3333 VSS.t73 VSS.t294 1.82123
R3334 VSS.n771 VSS.t115 1.82123
R3335 VSS.t272 VSS.t96 1.82123
R3336 VSS.n795 VSS.t53 1.82123
R3337 VSS.n663 VSS.t53 1.82123
R3338 VSS.n693 VSS.t49 1.82123
R3339 VSS.n636 VSS.t262 1.82123
R3340 VSS.t303 VSS.t28 1.82123
R3341 VSS.t76 VSS.t288 1.82123
R3342 VSS.n727 VSS.t74 1.82123
R3343 VSS.t289 VSS.t74 1.82123
R3344 VSS.t211 VSS.n529 1.82123
R3345 VSS.n600 VSS.t316 1.82123
R3346 VSS.n171 VSS.t324 1.82123
R3347 VSS.t101 VSS.t275 1.82123
R3348 VSS.t99 VSS.t276 1.82123
R3349 VSS.n217 VSS.t141 1.82123
R3350 VSS.n200 VSS.t58 1.82123
R3351 VSS.n995 VSS.t58 1.82123
R3352 VSS.t147 VSS.t358 1.82123
R3353 VSS.t90 VSS.t353 1.82123
R3354 VSS.n1004 VSS.t152 1.82123
R3355 VSS.t355 VSS.n1014 1.82123
R3356 VSS.t45 VSS.t157 1.82123
R3357 VSS.t85 VSS.t156 1.82123
R3358 VSS.n1023 VSS.t224 1.82123
R3359 VSS.t337 VSS.n93 1.82123
R3360 VSS.n672 VSS.n671 1.75086
R3361 VSS.n646 VSS.n645 1.75086
R3362 VSS.n575 VSS.t306 1.63916
R3363 VSS.n576 VSS.t210 1.63916
R3364 VSS.n620 VSS.t316 1.63916
R3365 VSS.n619 VSS.t71 1.63916
R3366 VSS.t269 VSS.n611 1.63916
R3367 VSS.n980 VSS.t270 1.63916
R3368 VSS.n215 VSS.t309 1.63916
R3369 VSS.n374 VSS.n370 1.3505
R3370 VSS.n42 VSS.n38 1.3505
R3371 VSS.n390 VSS.n384 1.23208
R3372 VSS.n370 VSS.n367 1.23208
R3373 VSS.n38 VSS.n35 1.23208
R3374 VSS.n58 VSS.n52 1.23208
R3375 VSS.n813 VSS.n331 1.1255
R3376 VSS.n814 VSS.n813 1.1255
R3377 VSS.n816 VSS.n814 1.1255
R3378 VSS.n817 VSS.n816 1.1255
R3379 VSS.n818 VSS.n817 1.1255
R3380 VSS.n819 VSS.n818 1.1255
R3381 VSS.n819 VSS.n812 1.1255
R3382 VSS.n812 VSS.n811 1.1255
R3383 VSS.n811 VSS.n810 1.1255
R3384 VSS.n810 VSS.n809 1.1255
R3385 VSS.n809 VSS.n808 1.1255
R3386 VSS.n808 VSS.n805 1.1255
R3387 VSS.n805 VSS.n804 1.1255
R3388 VSS.n804 VSS.n492 1.1255
R3389 VSS.n570 VSS.n492 1.1255
R3390 VSS.n571 VSS.n570 1.1255
R3391 VSS.n572 VSS.n571 1.1255
R3392 VSS.n572 VSS.n569 1.1255
R3393 VSS.n582 VSS.n580 1.1255
R3394 VSS.n583 VSS.n582 1.1255
R3395 VSS.n585 VSS.n583 1.1255
R3396 VSS.n586 VSS.n585 1.1255
R3397 VSS.n589 VSS.n586 1.1255
R3398 VSS.n590 VSS.n589 1.1255
R3399 VSS.n593 VSS.n590 1.1255
R3400 VSS.n595 VSS.n593 1.1255
R3401 VSS.n596 VSS.n595 1.1255
R3402 VSS.n894 VSS.n318 1.1255
R3403 VSS.n900 VSS.n318 1.1255
R3404 VSS.n901 VSS.n900 1.1255
R3405 VSS.n902 VSS.n901 1.1255
R3406 VSS.n902 VSS.n317 1.1255
R3407 VSS.n823 VSS.n317 1.1255
R3408 VSS.n824 VSS.n823 1.1255
R3409 VSS.n825 VSS.n824 1.1255
R3410 VSS.n825 VSS.n481 1.1255
R3411 VSS.n831 VSS.n481 1.1255
R3412 VSS.n832 VSS.n831 1.1255
R3413 VSS.n833 VSS.n832 1.1255
R3414 VSS.n833 VSS.n480 1.1255
R3415 VSS.n799 VSS.n480 1.1255
R3416 VSS.n799 VSS.n798 1.1255
R3417 VSS.n798 VSS.n797 1.1255
R3418 VSS.n797 VSS.n497 1.1255
R3419 VSS.n568 VSS.n497 1.1255
R3420 VSS.n877 VSS.n876 1.1255
R3421 VSS.n878 VSS.n877 1.1255
R3422 VSS.n878 VSS.n328 1.1255
R3423 VSS.n883 VSS.n328 1.1255
R3424 VSS.n884 VSS.n883 1.1255
R3425 VSS.n885 VSS.n884 1.1255
R3426 VSS.n885 VSS.n326 1.1255
R3427 VSS.n326 VSS.n325 1.1255
R3428 VSS.n892 VSS.n325 1.1255
R3429 VSS.n219 VSS.n175 1.1255
R3430 VSS.n220 VSS.n219 1.1255
R3431 VSS.n221 VSS.n220 1.1255
R3432 VSS.n222 VSS.n221 1.1255
R3433 VSS.n224 VSS.n222 1.1255
R3434 VSS.n225 VSS.n224 1.1255
R3435 VSS.n226 VSS.n225 1.1255
R3436 VSS.n227 VSS.n226 1.1255
R3437 VSS.n228 VSS.n227 1.1255
R3438 VSS.n228 VSS.n148 1.1255
R3439 VSS.n148 VSS.n147 1.1255
R3440 VSS.n147 VSS.n146 1.1255
R3441 VSS.n146 VSS.n145 1.1255
R3442 VSS.n145 VSS.n143 1.1255
R3443 VSS.n143 VSS.n142 1.1255
R3444 VSS.n142 VSS.n141 1.1255
R3445 VSS.n141 VSS.n61 1.1255
R3446 VSS.n1031 VSS.n61 1.1255
R3447 VSS.n174 VSS.n149 1.1255
R3448 VSS.n158 VSS.n149 1.1255
R3449 VSS.n159 VSS.n158 1.1255
R3450 VSS.n162 VSS.n159 1.1255
R3451 VSS.n163 VSS.n162 1.1255
R3452 VSS.n166 VSS.n163 1.1255
R3453 VSS.n167 VSS.n166 1.1255
R3454 VSS.n168 VSS.n167 1.1255
R3455 VSS.n168 VSS.n156 1.1255
R3456 VSS.n992 VSS.n991 1.1255
R3457 VSS.n993 VSS.n992 1.1255
R3458 VSS.n993 VSS.n111 1.1255
R3459 VSS.n999 VSS.n111 1.1255
R3460 VSS.n1000 VSS.n999 1.1255
R3461 VSS.n1001 VSS.n1000 1.1255
R3462 VSS.n1001 VSS.n105 1.1255
R3463 VSS.n1008 VSS.n105 1.1255
R3464 VSS.n1009 VSS.n1008 1.1255
R3465 VSS.n1010 VSS.n1009 1.1255
R3466 VSS.n1010 VSS.n99 1.1255
R3467 VSS.n1017 VSS.n99 1.1255
R3468 VSS.n1018 VSS.n1017 1.1255
R3469 VSS.n1019 VSS.n1018 1.1255
R3470 VSS.n1019 VSS.n91 1.1255
R3471 VSS.n1025 VSS.n91 1.1255
R3472 VSS.n1026 VSS.n1025 1.1255
R3473 VSS.n1027 VSS.n1026 1.1255
R3474 VSS.n74 VSS.n60 1.1255
R3475 VSS.n75 VSS.n74 1.1255
R3476 VSS.n76 VSS.n75 1.1255
R3477 VSS.n76 VSS.n69 1.1255
R3478 VSS.n81 VSS.n69 1.1255
R3479 VSS.n82 VSS.n81 1.1255
R3480 VSS.n83 VSS.n82 1.1255
R3481 VSS.n83 VSS.n67 1.1255
R3482 VSS.n89 VSS.n67 1.1255
R3483 VSS.n518 VSS.t92 1.09294
R3484 VSS.n573 VSS.t76 1.09294
R3485 VSS.n868 VSS.n395 0.992495
R3486 VSS.n775 VSS.n395 0.991003
R3487 VSS.n909 VSS.n908 0.9905
R3488 VSS.n231 VSS.n230 0.910864
R3489 VSS.n256 VSS.n255 0.9005
R3490 VSS.n255 VSS.n254 0.9005
R3491 VSS.n254 VSS.n253 0.9005
R3492 VSS.n253 VSS.n252 0.9005
R3493 VSS.n252 VSS.n251 0.9005
R3494 VSS.n417 VSS.n416 0.878
R3495 VSS.n580 VSS.n569 0.878
R3496 VSS.n175 VSS.n174 0.878
R3497 VSS.n845 VSS.t163 0.8195
R3498 VSS.n845 VSS.t164 0.8195
R3499 VSS.n846 VSS.t160 0.8195
R3500 VSS.n846 VSS.t161 0.8195
R3501 VSS.n291 VSS.n290 0.7655
R3502 VSS.n962 VSS.n138 0.7655
R3503 VSS.n682 VSS.n681 0.7655
R3504 VSS.n702 VSS.n544 0.7655
R3505 VSS.n746 VSS.n527 0.7655
R3506 VSS.n600 VSS.n599 0.73879
R3507 VSS.n87 VSS.n64 0.73879
R3508 VSS.n290 VSS.n284 0.6755
R3509 VSS.n285 VSS.n284 0.6755
R3510 VSS.n285 VSS.n261 0.6755
R3511 VSS.n918 VSS.n261 0.6755
R3512 VSS.n919 VSS.n918 0.6755
R3513 VSS.n920 VSS.n919 0.6755
R3514 VSS.n920 VSS.n258 0.6755
R3515 VSS.n925 VSS.n258 0.6755
R3516 VSS.n926 VSS.n925 0.6755
R3517 VSS.n292 VSS.n291 0.6755
R3518 VSS.n292 VSS.n280 0.6755
R3519 VSS.n298 VSS.n280 0.6755
R3520 VSS.n299 VSS.n298 0.6755
R3521 VSS.n300 VSS.n299 0.6755
R3522 VSS.n300 VSS.n276 0.6755
R3523 VSS.n306 VSS.n276 0.6755
R3524 VSS.n307 VSS.n306 0.6755
R3525 VSS.n308 VSS.n307 0.6755
R3526 VSS.n308 VSS.n272 0.6755
R3527 VSS.n908 VSS.n272 0.6755
R3528 VSS.n910 VSS.n909 0.6755
R3529 VSS.n910 VSS.n271 0.6755
R3530 VSS.n468 VSS.n271 0.6755
R3531 VSS.n468 VSS.n467 0.6755
R3532 VSS.n467 VSS.n466 0.6755
R3533 VSS.n466 VSS.n403 0.6755
R3534 VSS.n412 VSS.n403 0.6755
R3535 VSS.n415 VSS.n412 0.6755
R3536 VSS.n416 VSS.n415 0.6755
R3537 VSS.n928 VSS.n247 0.6755
R3538 VSS.n939 VSS.n247 0.6755
R3539 VSS.n940 VSS.n939 0.6755
R3540 VSS.n941 VSS.n940 0.6755
R3541 VSS.n941 VSS.n246 0.6755
R3542 VSS.n246 VSS.n240 0.6755
R3543 VSS.n951 VSS.n240 0.6755
R3544 VSS.n952 VSS.n951 0.6755
R3545 VSS.n953 VSS.n952 0.6755
R3546 VSS.n953 VSS.n239 0.6755
R3547 VSS.n417 VSS.n239 0.6755
R3548 VSS.n865 VSS.n398 0.6755
R3549 VSS.n460 VSS.n398 0.6755
R3550 VSS.n460 VSS.n459 0.6755
R3551 VSS.n459 VSS.n458 0.6755
R3552 VSS.n458 VSS.n407 0.6755
R3553 VSS.n444 VSS.n407 0.6755
R3554 VSS.n447 VSS.n444 0.6755
R3555 VSS.n448 VSS.n447 0.6755
R3556 VSS.n451 VSS.n448 0.6755
R3557 VSS.n452 VSS.n451 0.6755
R3558 VSS.n437 VSS.n434 0.6755
R3559 VSS.n434 VSS.n433 0.6755
R3560 VSS.n433 VSS.n430 0.6755
R3561 VSS.n430 VSS.n429 0.6755
R3562 VSS.n429 VSS.n139 0.6755
R3563 VSS.n960 VSS.n139 0.6755
R3564 VSS.n961 VSS.n960 0.6755
R3565 VSS.n962 VSS.n961 0.6755
R3566 VSS.n683 VSS.n682 0.6755
R3567 VSS.n683 VSS.n677 0.6755
R3568 VSS.n689 VSS.n677 0.6755
R3569 VSS.n690 VSS.n689 0.6755
R3570 VSS.n691 VSS.n690 0.6755
R3571 VSS.n691 VSS.n676 0.6755
R3572 VSS.n676 VSS.n675 0.6755
R3573 VSS.n675 VSS.n556 0.6755
R3574 VSS.n614 VSS.n556 0.6755
R3575 VSS.n614 VSS.n613 0.6755
R3576 VSS.n858 VSS.n857 0.6755
R3577 VSS.n858 VSS.n851 0.6755
R3578 VSS.n851 VSS.n850 0.6755
R3579 VSS.n844 VSS.n841 0.6755
R3580 VSS.n841 VSS.n840 0.6755
R3581 VSS.n840 VSS.n474 0.6755
R3582 VSS.n681 VSS.n474 0.6755
R3583 VSS.n782 VSS.n510 0.6755
R3584 VSS.n783 VSS.n782 0.6755
R3585 VSS.n784 VSS.n783 0.6755
R3586 VSS.n784 VSS.n508 0.6755
R3587 VSS.n508 VSS.n506 0.6755
R3588 VSS.n791 VSS.n506 0.6755
R3589 VSS.n711 VSS.n710 0.6755
R3590 VSS.n711 VSS.n542 0.6755
R3591 VSS.n716 VSS.n542 0.6755
R3592 VSS.n717 VSS.n716 0.6755
R3593 VSS.n717 VSS.n540 0.6755
R3594 VSS.n722 VSS.n540 0.6755
R3595 VSS.n760 VSS.n755 0.6755
R3596 VSS.n761 VSS.n760 0.6755
R3597 VSS.n762 VSS.n761 0.6755
R3598 VSS.n762 VSS.n523 0.6755
R3599 VSS.n767 VSS.n523 0.6755
R3600 VSS.n768 VSS.n767 0.6755
R3601 VSS.n530 VSS.n526 0.6755
R3602 VSS.n739 VSS.n530 0.6755
R3603 VSS.n739 VSS.n738 0.6755
R3604 VSS.n738 VSS.n737 0.6755
R3605 VSS.n737 VSS.n532 0.6755
R3606 VSS.n731 VSS.n532 0.6755
R3607 VSS.n654 VSS.n652 0.6755
R3608 VSS.n655 VSS.n654 0.6755
R3609 VSS.n658 VSS.n655 0.6755
R3610 VSS.n659 VSS.n658 0.6755
R3611 VSS.n660 VSS.n659 0.6755
R3612 VSS.n660 VSS.n651 0.6755
R3613 VSS.n651 VSS.n552 0.6755
R3614 VSS.n696 VSS.n695 0.6755
R3615 VSS.n697 VSS.n696 0.6755
R3616 VSS.n697 VSS.n551 0.6755
R3617 VSS.n616 VSS.n551 0.6755
R3618 VSS.n616 VSS.n133 0.6755
R3619 VSS.n968 VSS.n133 0.6755
R3620 VSS.n969 VSS.n968 0.6755
R3621 VSS.n970 VSS.n969 0.6755
R3622 VSS.n970 VSS.n125 0.6755
R3623 VSS.n984 VSS.n125 0.6755
R3624 VSS.n985 VSS.n984 0.6755
R3625 VSS.n986 VSS.n985 0.6755
R3626 VSS.n986 VSS.n124 0.6755
R3627 VSS.n205 VSS.n124 0.6755
R3628 VSS.n206 VSS.n205 0.6755
R3629 VSS.n196 VSS.n195 0.6755
R3630 VSS.n197 VSS.n196 0.6755
R3631 VSS.n197 VSS.n189 0.6755
R3632 VSS.n189 VSS.n188 0.6755
R3633 VSS.n188 VSS.n181 0.6755
R3634 VSS.n203 VSS.n181 0.6755
R3635 VSS.n204 VSS.n203 0.6755
R3636 VSS.n669 VSS.n668 0.6755
R3637 VSS.n669 VSS.n624 0.6755
R3638 VSS.n624 VSS.n623 0.6755
R3639 VSS.n623 VSS.n559 0.6755
R3640 VSS.n607 VSS.n559 0.6755
R3641 VSS.n607 VSS.n606 0.6755
R3642 VSS.n606 VSS.n605 0.6755
R3643 VSS.n605 VSS.n129 0.6755
R3644 VSS.n975 VSS.n129 0.6755
R3645 VSS.n976 VSS.n975 0.6755
R3646 VSS.n977 VSS.n976 0.6755
R3647 VSS.n977 VSS.n128 0.6755
R3648 VSS.n212 VSS.n128 0.6755
R3649 VSS.n212 VSS.n211 0.6755
R3650 VSS.n211 VSS.n210 0.6755
R3651 VSS.n453 VSS.n443 0.653
R3652 VSS.n210 VSS.n177 0.653
R3653 VSS.n597 VSS.n568 0.653
R3654 VSS.n894 VSS.n893 0.653
R3655 VSS.n991 VSS.n118 0.653
R3656 VSS.n1027 VSS.n90 0.653
R3657 VSS.n652 VSS.n628 0.563
R3658 VSS.n195 VSS.n193 0.563
R3659 VSS.n723 VSS.n722 0.5405
R3660 VSS.n731 VSS.n730 0.5405
R3661 VSS.n695 VSS.n552 0.5405
R3662 VSS.n206 VSS.n204 0.5405
R3663 VSS.n873 VSS.n331 0.518
R3664 VSS.n1032 VSS.n1031 0.518
R3665 VSS.n927 VSS.n926 0.47417
R3666 VSS.n453 VSS.n452 0.4505
R3667 VSS.n442 VSS.n437 0.4505
R3668 VSS.n613 VSS.n138 0.4505
R3669 VSS.n857 VSS.n856 0.4505
R3670 VSS.n793 VSS.n792 0.4505
R3671 VSS.n793 VSS.n505 0.4505
R3672 VSS.n724 VSS.n505 0.4505
R3673 VSS.n725 VSS.n724 0.4505
R3674 VSS.n725 VSS.n723 0.4505
R3675 VSS.n632 VSS.n514 0.4505
R3676 VSS.n633 VSS.n632 0.4505
R3677 VSS.n634 VSS.n633 0.4505
R3678 VSS.n634 VSS.n631 0.4505
R3679 VSS.n631 VSS.n544 0.4505
R3680 VSS.n769 VSS.n522 0.4505
R3681 VSS.n642 VSS.n522 0.4505
R3682 VSS.n642 VSS.n534 0.4505
R3683 VSS.n729 VSS.n534 0.4505
R3684 VSS.n730 VSS.n729 0.4505
R3685 VSS.n773 VSS.n516 0.4505
R3686 VSS.n640 VSS.n516 0.4505
R3687 VSS.n640 VSS.n639 0.4505
R3688 VSS.n639 VSS.n638 0.4505
R3689 VSS.n638 VSS.n527 0.4505
R3690 VSS.n259 VSS.n249 0.430889
R3691 VSS.n922 VSS.n249 0.430889
R3692 VSS.n422 VSS.n409 0.430889
R3693 VSS.n422 VSS.n410 0.430889
R3694 VSS.n464 VSS.n463 0.430889
R3695 VSS.n455 VSS.n425 0.430889
R3696 VSS.n455 VSS.n424 0.430889
R3697 VSS.n455 VSS.n423 0.430889
R3698 VSS.n456 VSS.n455 0.430889
R3699 VSS.n957 VSS.n232 0.430889
R3700 VSS.n957 VSS.n233 0.430889
R3701 VSS.n957 VSS.n234 0.430889
R3702 VSS.n958 VSS.n957 0.430889
R3703 VSS.n663 VSS.n662 0.430889
R3704 VSS.n663 VSS.n648 0.430889
R3705 VSS.n663 VSS.n647 0.430889
R3706 VSS.n664 VSS.n663 0.430889
R3707 VSS.n200 VSS.n184 0.430889
R3708 VSS.n200 VSS.n199 0.430889
R3709 VSS.n200 VSS.n183 0.430889
R3710 VSS.n201 VSS.n200 0.430889
R3711 VSS.n789 VSS.n507 0.430889
R3712 VSS.n786 VSS.n507 0.430889
R3713 VSS.n511 VSS.n507 0.430889
R3714 VSS.n779 VSS.n507 0.430889
R3715 VSS.n545 VSS.n529 0.430889
R3716 VSS.n713 VSS.n529 0.430889
R3717 VSS.n541 VSS.n529 0.430889
R3718 VSS.n720 VSS.n529 0.430889
R3719 VSS.n524 VSS.n507 0.430889
R3720 VSS.n764 VSS.n507 0.430889
R3721 VSS.n756 VSS.n507 0.430889
R3722 VSS.n757 VSS.n507 0.430889
R3723 VSS.n744 VSS.n529 0.430889
R3724 VSS.n741 VSS.n529 0.430889
R3725 VSS.n735 VSS.n529 0.430889
R3726 VSS.n733 VSS.n529 0.430889
R3727 VSS.n837 VSS.n836 0.430889
R3728 VSS.n965 VSS.n964 0.430889
R3729 VSS.n861 VSS.n471 0.430889
R3730 VSS.n861 VSS.n472 0.430889
R3731 VSS.n861 VSS.n860 0.430889
R3732 VSS.n862 VSS.n861 0.430889
R3733 VSS.n462 VSS.n399 0.430889
R3734 VSS.n871 VSS.n390 0.379447
R3735 VSS.n1034 VSS.n58 0.379447
R3736 VSS.n866 VSS.n865 0.37175
R3737 VSS.n776 VSS.n514 0.37175
R3738 VSS.n774 VSS.n773 0.37175
R3739 VSS.n668 VSS.n667 0.37175
R3740 VSS.n777 VSS.n513 0.366125
R3741 VSS.n709 VSS.n702 0.366125
R3742 VSS.n754 VSS.n515 0.366125
R3743 VSS.n747 VSS.n746 0.366125
R3744 VSS.n850 VSS.n848 0.3605
R3745 VSS.n876 VSS.n873 0.3605
R3746 VSS.n1032 VSS.n60 0.3605
R3747 VSS.n597 VSS.n596 0.338
R3748 VSS.n893 VSS.n892 0.338
R3749 VSS.n156 VSS.n118 0.338
R3750 VSS.n90 VSS.n89 0.338
R3751 VSS.n848 VSS.n844 0.3155
R3752 VSS.n792 VSS.n791 0.3155
R3753 VSS.n769 VSS.n768 0.3155
R3754 VSS.n513 VSS.n510 0.309875
R3755 VSS.n710 VSS.n709 0.309875
R3756 VSS.n755 VSS.n754 0.309875
R3757 VSS.n747 VSS.n526 0.309875
R3758 VSS.n866 VSS.n397 0.28175
R3759 VSS.n667 VSS.n666 0.28175
R3760 VSS.n890 VSS.n323 0.2772
R3761 VSS.n887 VSS.n323 0.2772
R3762 VSS.n329 VSS.n323 0.2772
R3763 VSS.n880 VSS.n323 0.2772
R3764 VSS.n874 VSS.n323 0.2772
R3765 VSS.n600 VSS.n563 0.2772
R3766 VSS.n600 VSS.n562 0.2772
R3767 VSS.n600 VSS.n561 0.2772
R3768 VSS.n600 VSS.n565 0.2772
R3769 VSS.n171 VSS.n170 0.2772
R3770 VSS.n171 VSS.n153 0.2772
R3771 VSS.n171 VSS.n152 0.2772
R3772 VSS.n171 VSS.n151 0.2772
R3773 VSS.n172 VSS.n171 0.2772
R3774 VSS.n72 VSS.n64 0.2772
R3775 VSS.n78 VSS.n64 0.2772
R3776 VSS.n70 VSS.n64 0.2772
R3777 VSS.n85 VSS.n64 0.2772
R3778 VSS.n1035 VSS.n0 0.2255
R3779 VSS.n443 VSS.n442 0.2255
R3780 VSS.n856 VSS.n397 0.2255
R3781 VSS.n333 VSS.t75 0.20525
R3782 VSS.n333 VSS.t364 0.20525
R3783 VSS.n334 VSS.t79 0.20525
R3784 VSS.n334 VSS.t77 0.20525
R3785 VSS.n336 VSS.t31 0.20525
R3786 VSS.n336 VSS.t29 0.20525
R3787 VSS.n339 VSS.t52 0.20525
R3788 VSS.n339 VSS.t50 0.20525
R3789 VSS.n340 VSS.t93 0.20525
R3790 VSS.n340 VSS.t54 0.20525
R3791 VSS.n342 VSS.t97 0.20525
R3792 VSS.n342 VSS.t95 0.20525
R3793 VSS.n345 VSS.t116 0.20525
R3794 VSS.n345 VSS.t114 0.20525
R3795 VSS.n349 VSS.t297 0.20525
R3796 VSS.n349 VSS.t295 0.20525
R3797 VSS.n348 VSS.t301 0.20525
R3798 VSS.n348 VSS.t299 0.20525
R3799 VSS.n353 VSS.t134 0.20525
R3800 VSS.n353 VSS.t136 0.20525
R3801 VSS.n354 VSS.t132 0.20525
R3802 VSS.n354 VSS.t133 0.20525
R3803 VSS.n356 VSS.t130 0.20525
R3804 VSS.n356 VSS.t131 0.20525
R3805 VSS.n357 VSS.t14 0.20525
R3806 VSS.n357 VSS.t4 0.20525
R3807 VSS.n358 VSS.t12 0.20525
R3808 VSS.n358 VSS.t10 0.20525
R3809 VSS.n360 VSS.t6 0.20525
R3810 VSS.n360 VSS.t8 0.20525
R3811 VSS.n365 VSS.t128 0.20525
R3812 VSS.n365 VSS.t129 0.20525
R3813 VSS.n376 VSS.t151 0.20525
R3814 VSS.n376 VSS.t149 0.20525
R3815 VSS.n377 VSS.t187 0.20525
R3816 VSS.n377 VSS.t185 0.20525
R3817 VSS.n379 VSS.t120 0.20525
R3818 VSS.n379 VSS.t189 0.20525
R3819 VSS.n382 VSS.t124 0.20525
R3820 VSS.n382 VSS.t122 0.20525
R3821 VSS.n385 VSS.t232 0.20525
R3822 VSS.n385 VSS.t230 0.20525
R3823 VSS.n386 VSS.t213 0.20525
R3824 VSS.n386 VSS.t234 0.20525
R3825 VSS.n388 VSS.t217 0.20525
R3826 VSS.n388 VSS.t215 0.20525
R3827 VSS.n372 VSS.t279 0.20525
R3828 VSS.n372 VSS.t191 0.20525
R3829 VSS.n371 VSS.t26 0.20525
R3830 VSS.n371 VSS.t66 0.20525
R3831 VSS.n368 VSS.t236 0.20525
R3832 VSS.n368 VSS.t238 0.20525
R3833 VSS.n53 VSS.t344 0.20525
R3834 VSS.n53 VSS.t342 0.20525
R3835 VSS.n55 VSS.t348 0.20525
R3836 VSS.n55 VSS.t346 0.20525
R3837 VSS.n54 VSS.t340 0.20525
R3838 VSS.n54 VSS.t338 0.20525
R3839 VSS.n44 VSS.t223 0.20525
R3840 VSS.n44 VSS.t366 0.20525
R3841 VSS.n48 VSS.t227 0.20525
R3842 VSS.n48 VSS.t225 0.20525
R3843 VSS.n46 VSS.t331 0.20525
R3844 VSS.n46 VSS.t329 0.20525
R3845 VSS.n45 VSS.t111 0.20525
R3846 VSS.n45 VSS.t333 0.20525
R3847 VSS.n39 VSS.t46 0.20525
R3848 VSS.n39 VSS.t86 0.20525
R3849 VSS.n40 VSS.t311 0.20525
R3850 VSS.n40 VSS.t48 0.20525
R3851 VSS.n21 VSS.t205 0.20525
R3852 VSS.n21 VSS.t207 0.20525
R3853 VSS.n22 VSS.t254 0.20525
R3854 VSS.n22 VSS.t255 0.20525
R3855 VSS.n24 VSS.t252 0.20525
R3856 VSS.n24 VSS.t253 0.20525
R3857 VSS.n23 VSS.t250 0.20525
R3858 VSS.n23 VSS.t251 0.20525
R3859 VSS.n32 VSS.t193 0.20525
R3860 VSS.n32 VSS.t203 0.20525
R3861 VSS.n30 VSS.t199 0.20525
R3862 VSS.n30 VSS.t201 0.20525
R3863 VSS.n29 VSS.t195 0.20525
R3864 VSS.n29 VSS.t197 0.20525
R3865 VSS.n36 VSS.t181 0.20525
R3866 VSS.n36 VSS.t183 0.20525
R3867 VSS.n7 VSS.t20 0.20525
R3868 VSS.n7 VSS.t155 0.20525
R3869 VSS.n11 VSS.t24 0.20525
R3870 VSS.n11 VSS.t22 0.20525
R3871 VSS.n9 VSS.t59 0.20525
R3872 VSS.n9 VSS.t57 0.20525
R3873 VSS.n8 VSS.t126 0.20525
R3874 VSS.n8 VSS.t61 0.20525
R3875 VSS.n1 VSS.t142 0.20525
R3876 VSS.n1 VSS.t140 0.20525
R3877 VSS.n3 VSS.t100 0.20525
R3878 VSS.n3 VSS.t144 0.20525
R3879 VSS.n2 VSS.t104 0.20525
R3880 VSS.n2 VSS.t102 0.20525
R3881 VSS.n16 VSS.t352 0.20525
R3882 VSS.n16 VSS.t357 0.20525
R3883 VSS.n17 VSS.t359 0.20525
R3884 VSS.n17 VSS.t354 0.20525
R3885 VSS.n707 VSS.n706 0.189974
R3886 VSS.n752 VSS.n750 0.189974
R3887 VSS.n367 VSS.n352 0.189974
R3888 VSS.n343 VSS.n341 0.189974
R3889 VSS.n366 VSS.n364 0.189974
R3890 VSS.n364 VSS.n355 0.189974
R3891 VSS.n380 VSS.n378 0.189974
R3892 VSS.n35 VSS.n20 0.189974
R3893 VSS.n49 VSS.n47 0.189974
R3894 VSS.n33 VSS.n31 0.189974
R3895 VSS.n34 VSS.n33 0.189974
R3896 VSS.n12 VSS.n10 0.189974
R3897 VSS.n928 VSS.n927 0.178383
R3898 VSS.n777 VSS.n776 0.16925
R3899 VSS.n774 VSS.n515 0.16925
R3900 VSS.n191 VSS.t327 0.1643
R3901 VSS.n191 VSS.t315 0.1643
R3902 VSS.n190 VSS.t323 0.1643
R3903 VSS.n190 VSS.t325 0.1643
R3904 VSS.n626 VSS.t317 0.1643
R3905 VSS.n626 VSS.t321 0.1643
R3906 VSS.n625 VSS.t313 0.1643
R3907 VSS.n625 VSS.t319 0.1643
R3908 VSS.n852 VSS.t168 0.1643
R3909 VSS.n852 VSS.t170 0.1643
R3910 VSS.n854 VSS.t167 0.1643
R3911 VSS.n854 VSS.t166 0.1643
R3912 VSS.n438 VSS.t174 0.1643
R3913 VSS.n438 VSS.t176 0.1643
R3914 VSS.n439 VSS.t173 0.1643
R3915 VSS.n439 VSS.t172 0.1643
R3916 VSS.n708 VSS.n703 0.1605
R3917 VSS.n753 VSS.n748 0.1605
R3918 VSS.n704 VSS.t257 0.137
R3919 VSS.n704 VSS.t263 0.137
R3920 VSS.n705 VSS.t264 0.137
R3921 VSS.n705 VSS.t259 0.137
R3922 VSS.n749 VSS.t266 0.137
R3923 VSS.n749 VSS.t267 0.137
R3924 VSS.n751 VSS.t261 0.137
R3925 VSS.n751 VSS.t265 0.137
R3926 VSS.n441 VSS.n440 0.118945
R3927 VSS.n855 VSS.n853 0.117954
R3928 VSS.n666 VSS.n628 0.113
R3929 VSS.n193 VSS.n177 0.113
R3930 VSS.n384 VSS.n375 0.0952368
R3931 VSS.n347 VSS.n338 0.0952368
R3932 VSS.n337 VSS.n335 0.0952368
R3933 VSS.n346 VSS.n344 0.0952368
R3934 VSS.n344 VSS.n343 0.0952368
R3935 VSS.n361 VSS.n359 0.0952368
R3936 VSS.n383 VSS.n381 0.0952368
R3937 VSS.n381 VSS.n380 0.0952368
R3938 VSS.n389 VSS.n387 0.0952368
R3939 VSS.n15 VSS.n6 0.0952368
R3940 VSS.n52 VSS.n43 0.0952368
R3941 VSS.n57 VSS.n56 0.0952368
R3942 VSS.n50 VSS.n49 0.0952368
R3943 VSS.n51 VSS.n50 0.0952368
R3944 VSS.n26 VSS.n25 0.0952368
R3945 VSS.n13 VSS.n12 0.0952368
R3946 VSS.n14 VSS.n13 0.0952368
R3947 VSS.n5 VSS.n4 0.0952368
R3948 VSS VSS.n1035 0.0455
R3949 VSS.n393 VSS.n391 0.0436507
R3950 VSS.n396 VSS.n391 0.0436507
R3951 VSS.n869 VSS.n391 0.008375
R3952 VSS.n867 VSS.n392 0.004
R3953 VSS.n868 VSS.n867 0.004
R3954 a_n6400_n23452.n1 a_n6400_n23452.t0 16.0839
R3955 a_n6400_n23452.n2 a_n6400_n23452.n1 12.3065
R3956 a_n6400_n23452.n1 a_n6400_n23452.n0 10.9378
R3957 a_n6400_n23452.n2 a_n6400_n23452.t2 0.1825
R3958 a_n6400_n23452.t1 a_n6400_n23452.n2 0.1825
R3959 a_n6400_n23452.n0 a_n6400_n23452.t3 0.1643
R3960 a_n6400_n23452.n0 a_n6400_n23452.t4 0.1643
R3961 a_n7157_n23500.n1 a_n7157_n23500.t4 16.0839
R3962 a_n7157_n23500.n0 a_n7157_n23500.t2 6.66284
R3963 a_n7157_n23500.n2 a_n7157_n23500.t0 6.62866
R3964 a_n7157_n23500.n0 a_n7157_n23500.t3 6.45713
R3965 a_n7157_n23500.t1 a_n7157_n23500.n2 6.42295
R3966 a_n7157_n23500.n1 a_n7157_n23500.n0 5.97129
R3967 a_n7157_n23500.n2 a_n7157_n23500.n1 4.55024
R3968 a_n10800_n23372.n0 a_n10800_n23372.t3 139.69
R3969 a_n10800_n23372.n0 a_n10800_n23372.t2 139.69
R3970 a_n10800_n23372.n1 a_n10800_n23372.n0 36.7175
R3971 a_n10800_n23372.n1 a_n10800_n23372.t1 14.2148
R3972 a_n10800_n23372.t0 a_n10800_n23372.n1 11.6368
R3973 a_n6400_n21652.n1 a_n6400_n21652.t2 16.0839
R3974 a_n6400_n21652.n1 a_n6400_n21652.n0 12.3065
R3975 a_n6400_n21652.n2 a_n6400_n21652.n1 10.9378
R3976 a_n6400_n21652.n0 a_n6400_n21652.t4 0.1825
R3977 a_n6400_n21652.n0 a_n6400_n21652.t3 0.1825
R3978 a_n6400_n21652.n2 a_n6400_n21652.t1 0.1643
R3979 a_n6400_n21652.t0 a_n6400_n21652.n2 0.1643
R3980 a_n7157_n21700.n1 a_n7157_n21700.t0 16.0839
R3981 a_n7157_n21700.n0 a_n7157_n21700.t2 6.66284
R3982 a_n7157_n21700.t3 a_n7157_n21700.n2 6.62866
R3983 a_n7157_n21700.n0 a_n7157_n21700.t1 6.45713
R3984 a_n7157_n21700.n2 a_n7157_n21700.t4 6.42295
R3985 a_n7157_n21700.n1 a_n7157_n21700.n0 5.97129
R3986 a_n7157_n21700.n2 a_n7157_n21700.n1 4.55024
R3987 a_n10800_n21572.n0 a_n10800_n21572.t3 139.69
R3988 a_n10800_n21572.n0 a_n10800_n21572.t2 139.69
R3989 a_n10800_n21572.n1 a_n10800_n21572.n0 36.7175
R3990 a_n10800_n21572.n1 a_n10800_n21572.t1 14.2148
R3991 a_n10800_n21572.t0 a_n10800_n21572.n1 11.6368
R3992 a_n6400_n19852.n1 a_n6400_n19852.t0 16.1006
R3993 a_n6400_n19852.n1 a_n6400_n19852.n0 12.3065
R3994 a_n6400_n19852.n2 a_n6400_n19852.n1 10.9378
R3995 a_n6400_n19852.n0 a_n6400_n19852.t2 0.1825
R3996 a_n6400_n19852.n0 a_n6400_n19852.t3 0.1825
R3997 a_n6400_n19852.n2 a_n6400_n19852.t4 0.1643
R3998 a_n6400_n19852.t1 a_n6400_n19852.n2 0.1643
R3999 a_n7300_n19900.n1 a_n7300_n19900.t1 16.1006
R4000 a_n7300_n19900.n0 a_n7300_n19900.t4 6.66284
R4001 a_n7300_n19900.n2 a_n7300_n19900.t2 6.62866
R4002 a_n7300_n19900.n0 a_n7300_n19900.t0 6.45713
R4003 a_n7300_n19900.t3 a_n7300_n19900.n2 6.42295
R4004 a_n7300_n19900.n1 a_n7300_n19900.n0 5.97129
R4005 a_n7300_n19900.n2 a_n7300_n19900.n1 4.55024
R4006 a_n10800_n19772.n0 a_n10800_n19772.t3 139.69
R4007 a_n10800_n19772.n0 a_n10800_n19772.t2 139.69
R4008 a_n10800_n19772.n1 a_n10800_n19772.n0 36.7175
R4009 a_n10800_n19772.n1 a_n10800_n19772.t1 14.2148
R4010 a_n10800_n19772.t0 a_n10800_n19772.n1 11.6368
R4011 a_n6400_n18052.n1 a_n6400_n18052.t2 16.1006
R4012 a_n6400_n18052.n2 a_n6400_n18052.n1 12.3065
R4013 a_n6400_n18052.n1 a_n6400_n18052.n0 10.9378
R4014 a_n6400_n18052.t0 a_n6400_n18052.n2 0.1825
R4015 a_n6400_n18052.n2 a_n6400_n18052.t1 0.1825
R4016 a_n6400_n18052.n0 a_n6400_n18052.t3 0.1643
R4017 a_n6400_n18052.n0 a_n6400_n18052.t4 0.1643
R4018 a_n7300_n18100.n1 a_n7300_n18100.t3 16.1006
R4019 a_n7300_n18100.n0 a_n7300_n18100.t2 6.66284
R4020 a_n7300_n18100.n2 a_n7300_n18100.t0 6.62866
R4021 a_n7300_n18100.n0 a_n7300_n18100.t4 6.45713
R4022 a_n7300_n18100.t1 a_n7300_n18100.n2 6.42295
R4023 a_n7300_n18100.n1 a_n7300_n18100.n0 5.97129
R4024 a_n7300_n18100.n2 a_n7300_n18100.n1 4.55024
R4025 a_n10800_n17972.n0 a_n10800_n17972.t3 139.69
R4026 a_n10800_n17972.n0 a_n10800_n17972.t2 139.69
R4027 a_n10800_n17972.n1 a_n10800_n17972.n0 36.7175
R4028 a_n10800_n17972.n1 a_n10800_n17972.t1 14.2148
R4029 a_n10800_n17972.t0 a_n10800_n17972.n1 11.6368
R4030 a_n6400_n16252.n1 a_n6400_n16252.t0 16.1006
R4031 a_n6400_n16252.n1 a_n6400_n16252.n0 12.3065
R4032 a_n6400_n16252.n2 a_n6400_n16252.n1 10.9378
R4033 a_n6400_n16252.n0 a_n6400_n16252.t2 0.1825
R4034 a_n6400_n16252.n0 a_n6400_n16252.t3 0.1825
R4035 a_n6400_n16252.n2 a_n6400_n16252.t4 0.1643
R4036 a_n6400_n16252.t1 a_n6400_n16252.n2 0.1643
R4037 a_n7300_n16300.n1 a_n7300_n16300.t0 16.1006
R4038 a_n7300_n16300.n0 a_n7300_n16300.t4 6.66284
R4039 a_n7300_n16300.n2 a_n7300_n16300.t2 6.62866
R4040 a_n7300_n16300.n0 a_n7300_n16300.t1 6.45713
R4041 a_n7300_n16300.t3 a_n7300_n16300.n2 6.42295
R4042 a_n7300_n16300.n1 a_n7300_n16300.n0 5.97129
R4043 a_n7300_n16300.n2 a_n7300_n16300.n1 4.55024
R4044 a_n10800_n16172.n0 a_n10800_n16172.t3 139.69
R4045 a_n10800_n16172.n0 a_n10800_n16172.t2 139.69
R4046 a_n10800_n16172.n1 a_n10800_n16172.n0 36.7175
R4047 a_n10800_n16172.n1 a_n10800_n16172.t1 14.2148
R4048 a_n10800_n16172.t0 a_n10800_n16172.n1 11.6368
R4049 a_n6400_n14452.n1 a_n6400_n14452.t2 16.1006
R4050 a_n6400_n14452.n2 a_n6400_n14452.n1 12.3065
R4051 a_n6400_n14452.n1 a_n6400_n14452.n0 10.9378
R4052 a_n6400_n14452.t0 a_n6400_n14452.n2 0.1825
R4053 a_n6400_n14452.n2 a_n6400_n14452.t1 0.1825
R4054 a_n6400_n14452.n0 a_n6400_n14452.t4 0.1643
R4055 a_n6400_n14452.n0 a_n6400_n14452.t3 0.1643
R4056 a_n7300_n14500.n1 a_n7300_n14500.t0 16.1006
R4057 a_n7300_n14500.n0 a_n7300_n14500.t4 6.66284
R4058 a_n7300_n14500.n2 a_n7300_n14500.t1 6.62866
R4059 a_n7300_n14500.n0 a_n7300_n14500.t3 6.45713
R4060 a_n7300_n14500.t2 a_n7300_n14500.n2 6.42295
R4061 a_n7300_n14500.n1 a_n7300_n14500.n0 5.97129
R4062 a_n7300_n14500.n2 a_n7300_n14500.n1 4.55024
R4063 a_n10800_n14372.n0 a_n10800_n14372.t3 139.69
R4064 a_n10800_n14372.n0 a_n10800_n14372.t2 139.69
R4065 a_n10800_n14372.n1 a_n10800_n14372.n0 36.7175
R4066 a_n10800_n14372.n1 a_n10800_n14372.t1 14.2148
R4067 a_n10800_n14372.t0 a_n10800_n14372.n1 11.6368
R4068 a_n6400_n12652.n1 a_n6400_n12652.t2 16.1006
R4069 a_n6400_n12652.n2 a_n6400_n12652.n1 12.3065
R4070 a_n6400_n12652.n1 a_n6400_n12652.n0 10.9378
R4071 a_n6400_n12652.n2 a_n6400_n12652.t1 0.1825
R4072 a_n6400_n12652.t0 a_n6400_n12652.n2 0.1825
R4073 a_n6400_n12652.n0 a_n6400_n12652.t3 0.1643
R4074 a_n6400_n12652.n0 a_n6400_n12652.t4 0.1643
R4075 a_n7300_n12700.n1 a_n7300_n12700.t2 16.1006
R4076 a_n7300_n12700.n0 a_n7300_n12700.t3 6.66284
R4077 a_n7300_n12700.n2 a_n7300_n12700.t0 6.62866
R4078 a_n7300_n12700.n0 a_n7300_n12700.t4 6.45713
R4079 a_n7300_n12700.t1 a_n7300_n12700.n2 6.42295
R4080 a_n7300_n12700.n1 a_n7300_n12700.n0 5.97129
R4081 a_n7300_n12700.n2 a_n7300_n12700.n1 4.55024
R4082 a_n10800_n12572.n0 a_n10800_n12572.t3 139.69
R4083 a_n10800_n12572.n0 a_n10800_n12572.t2 139.69
R4084 a_n10800_n12572.n1 a_n10800_n12572.n0 36.7175
R4085 a_n10800_n12572.n1 a_n10800_n12572.t1 14.2148
R4086 a_n10800_n12572.t0 a_n10800_n12572.n1 11.6368
R4087 a_2148_n500.n5 a_2148_n500.n3 10.5451
R4088 a_2148_n500.n5 a_2148_n500.n4 10.5451
R4089 a_2148_n500.n2 a_2148_n500.t0 6.45713
R4090 a_2148_n500.n8 a_2148_n500.n7 6.38754
R4091 a_2148_n500.n1 a_2148_n500.n0 6.29333
R4092 a_2148_n500.n6 a_2148_n500.n2 4.68405
R4093 a_2148_n500.n7 a_2148_n500.n6 2.22659
R4094 a_2148_n500.n6 a_2148_n500.n5 0.8055
R4095 a_2148_n500.n3 a_2148_n500.t7 0.3281
R4096 a_2148_n500.n3 a_2148_n500.t5 0.3281
R4097 a_2148_n500.n4 a_2148_n500.t8 0.3281
R4098 a_2148_n500.n4 a_2148_n500.t6 0.3281
R4099 a_2148_n500.n2 a_2148_n500.n1 0.189974
R4100 a_2148_n500.n8 a_2148_n500.t3 0.1643
R4101 a_2148_n500.t4 a_2148_n500.n8 0.1643
R4102 a_2148_n500.n0 a_2148_n500.t1 0.1643
R4103 a_2148_n500.n0 a_2148_n500.t2 0.1643
R4104 a_2148_n500.n7 a_2148_n500.n1 0.0928953
R4105 a_n5052_n1000.n5 a_n5052_n1000.n3 11.1933
R4106 a_n5052_n1000.n5 a_n5052_n1000.n4 11.1933
R4107 a_n5052_n1000.n2 a_n5052_n1000.t2 6.45713
R4108 a_n5052_n1000.n8 a_n5052_n1000.n7 6.38754
R4109 a_n5052_n1000.n1 a_n5052_n1000.n0 6.29333
R4110 a_n5052_n1000.n6 a_n5052_n1000.n2 4.68405
R4111 a_n5052_n1000.n7 a_n5052_n1000.n6 2.22659
R4112 a_n5052_n1000.n6 a_n5052_n1000.n5 0.5555
R4113 a_n5052_n1000.n2 a_n5052_n1000.n1 0.189974
R4114 a_n5052_n1000.n8 a_n5052_n1000.t5 0.1643
R4115 a_n5052_n1000.t6 a_n5052_n1000.n8 0.1643
R4116 a_n5052_n1000.n0 a_n5052_n1000.t3 0.1643
R4117 a_n5052_n1000.n0 a_n5052_n1000.t4 0.1643
R4118 a_n5052_n1000.n3 a_n5052_n1000.t1 0.1643
R4119 a_n5052_n1000.n3 a_n5052_n1000.t0 0.1643
R4120 a_n5052_n1000.n4 a_n5052_n1000.t8 0.1643
R4121 a_n5052_n1000.n4 a_n5052_n1000.t7 0.1643
R4122 a_n5052_n1000.n7 a_n5052_n1000.n1 0.0928953
R4123 a_n5052_2600.n3 a_n5052_2600.t7 7.27134
R4124 a_n5052_2600.n3 a_n5052_2600.t4 7.27134
R4125 a_n5052_2600.n2 a_n5052_2600.n0 6.71615
R4126 a_n5052_2600.n2 a_n5052_2600.n1 6.71615
R4127 a_n5052_2600.n4 a_n5052_2600.n3 6.31615
R4128 a_n5052_2600.n4 a_n5052_2600.t5 0.8195
R4129 a_n5052_2600.t6 a_n5052_2600.n4 0.8195
R4130 a_n5052_2600.n0 a_n5052_2600.t2 0.8195
R4131 a_n5052_2600.n0 a_n5052_2600.t3 0.8195
R4132 a_n5052_2600.n1 a_n5052_2600.t0 0.8195
R4133 a_n5052_2600.n1 a_n5052_2600.t1 0.8195
R4134 a_n5052_2600.n3 a_n5052_2600.n2 0.3955
R4135 a_5300_5958.t1 a_5300_5958.t0 26.7478
R4136 a_484_3500.t1 a_484_3500.t0 26.7478
R4137 a_n1900_5958.t1 a_n1900_5958.t0 26.7478
R4138 a_n3600_5641.n3 a_n3600_5641.t6 74.5091
R4139 a_n3600_5641.n3 a_n3600_5641.t7 74.5091
R4140 a_n3600_5641.n4 a_n3600_5641.n3 37.8057
R4141 a_n3600_5641.n1 a_n3600_5641.t5 13.0154
R4142 a_n3600_5641.n1 a_n3600_5641.t4 10.6142
R4143 a_n3600_5641.n0 a_n3600_5641.t2 7.23009
R4144 a_n3600_5641.n0 a_n3600_5641.t3 7.22685
R4145 a_n3600_5641.n5 a_n3600_5641.t0 6.55206
R4146 a_n3600_5641.t1 a_n3600_5641.n5 6.54882
R4147 a_n3600_5641.n5 a_n3600_5641.n4 2.75982
R4148 a_n3600_5641.n2 a_n3600_5641.n0 2.26891
R4149 a_n3600_5641.n2 a_n3600_5641.n1 0.425955
R4150 a_n3600_5641.n4 a_n3600_5641.n2 0.393227
R4151 a_n6572_3500.n3 a_n6572_3500.t6 74.5091
R4152 a_n6572_3500.n3 a_n6572_3500.t7 74.5091
R4153 a_n6572_3500.n4 a_n6572_3500.n3 37.5518
R4154 a_n6572_3500.n1 a_n6572_3500.t2 13.0154
R4155 a_n6572_3500.n1 a_n6572_3500.t5 10.6142
R4156 a_n6572_3500.n0 a_n6572_3500.t1 7.23009
R4157 a_n6572_3500.n0 a_n6572_3500.t0 7.22685
R4158 a_n6572_3500.t4 a_n6572_3500.n5 6.55206
R4159 a_n6572_3500.n5 a_n6572_3500.t3 6.54882
R4160 a_n6572_3500.n5 a_n6572_3500.n4 2.59618
R4161 a_n6572_3500.n2 a_n6572_3500.n0 2.26891
R4162 a_n6572_3500.n4 a_n6572_3500.n2 0.556864
R4163 a_n6572_3500.n2 a_n6572_3500.n1 0.425955
R4164 a_n6716_3500.t1 a_n6716_3500.t0 26.7478
R4165 a_n852_19400.n5 a_n852_19400.n3 10.7042
R4166 a_n852_19400.n5 a_n852_19400.n4 10.7042
R4167 a_n852_19400.t5 a_n852_19400.n7 6.77
R4168 a_n852_19400.n2 a_n852_19400.t2 6.6753
R4169 a_n852_19400.n1 a_n852_19400.n0 6.5388
R4170 a_n852_19400.n6 a_n852_19400.n2 4.63668
R4171 a_n852_19400.n7 a_n852_19400.n6 2.23814
R4172 a_n852_19400.n6 a_n852_19400.n5 0.5055
R4173 a_n852_19400.n2 a_n852_19400.n1 0.189974
R4174 a_n852_19400.n3 a_n852_19400.t6 0.1643
R4175 a_n852_19400.n3 a_n852_19400.t7 0.1643
R4176 a_n852_19400.n4 a_n852_19400.t0 0.1643
R4177 a_n852_19400.n4 a_n852_19400.t1 0.1643
R4178 a_n852_19400.n0 a_n852_19400.t3 0.137
R4179 a_n852_19400.n0 a_n852_19400.t4 0.137
R4180 a_n852_19400.n7 a_n852_19400.n1 0.0924286
R4181 a_n852_28800.n5 a_n852_28800.n3 10.7042
R4182 a_n852_28800.n5 a_n852_28800.n4 10.7042
R4183 a_n852_28800.t3 a_n852_28800.n7 6.77
R4184 a_n852_28800.n2 a_n852_28800.t0 6.6753
R4185 a_n852_28800.n1 a_n852_28800.n0 6.5388
R4186 a_n852_28800.n6 a_n852_28800.n2 4.63668
R4187 a_n852_28800.n7 a_n852_28800.n6 2.23814
R4188 a_n852_28800.n6 a_n852_28800.n5 0.5055
R4189 a_n852_28800.n2 a_n852_28800.n1 0.189974
R4190 a_n852_28800.n3 a_n852_28800.t6 0.1643
R4191 a_n852_28800.n3 a_n852_28800.t4 0.1643
R4192 a_n852_28800.n4 a_n852_28800.t5 0.1643
R4193 a_n852_28800.n4 a_n852_28800.t7 0.1643
R4194 a_n852_28800.n0 a_n852_28800.t1 0.137
R4195 a_n852_28800.n0 a_n852_28800.t2 0.137
R4196 a_n852_28800.n7 a_n852_28800.n1 0.0924286
R4197 a_600_22678.n0 a_600_22678.t4 139.689
R4198 a_600_22678.n0 a_600_22678.t3 139.689
R4199 a_600_22678.n1 a_600_22678.n0 37.2961
R4200 a_600_22678.n1 a_600_22678.t0 12.557
R4201 a_600_22678.n2 a_600_22678.t1 6.0613
R4202 a_600_22678.t2 a_600_22678.n2 6.0613
R4203 a_600_22678.n2 a_600_22678.n1 2.78832
R4204 a_n1000_22678.n0 a_n1000_22678.t4 139.689
R4205 a_n1000_22678.n0 a_n1000_22678.t3 139.689
R4206 a_n1000_22678.n1 a_n1000_22678.n0 37.2961
R4207 a_n1000_22678.n1 a_n1000_22678.t0 12.557
R4208 a_n1000_22678.n2 a_n1000_22678.t1 6.0613
R4209 a_n1000_22678.t2 a_n1000_22678.n2 6.0613
R4210 a_n1000_22678.n2 a_n1000_22678.n1 2.78832
R4211 a_11748_41600.n3 a_11748_41600.n1 10.7791
R4212 a_11748_41600.n3 a_11748_41600.n2 10.7791
R4213 a_11748_41600.n0 a_11748_41600.t7 6.55182
R4214 a_11748_41600.n5 a_11748_41600.t4 6.45713
R4215 a_11748_41600.n7 a_11748_41600.n6 6.29333
R4216 a_11748_41600.n5 a_11748_41600.n4 4.63668
R4217 a_11748_41600.n4 a_11748_41600.n0 2.23814
R4218 a_11748_41600.n4 a_11748_41600.n3 0.3305
R4219 a_11748_41600.n1 a_11748_41600.t2 0.20525
R4220 a_11748_41600.n1 a_11748_41600.t3 0.20525
R4221 a_11748_41600.n2 a_11748_41600.t0 0.20525
R4222 a_11748_41600.n2 a_11748_41600.t1 0.20525
R4223 a_11748_41600.n6 a_11748_41600.n5 0.189974
R4224 a_11748_41600.n7 a_11748_41600.t5 0.1643
R4225 a_11748_41600.t6 a_11748_41600.n7 0.1643
R4226 a_11748_41600.n6 a_11748_41600.n0 0.0924286
R4227 a_2148_41600.n3 a_2148_41600.n1 10.7791
R4228 a_2148_41600.n3 a_2148_41600.n2 10.7791
R4229 a_2148_41600.n0 a_2148_41600.t7 6.55182
R4230 a_2148_41600.n5 a_2148_41600.t4 6.45713
R4231 a_2148_41600.n7 a_2148_41600.n6 6.29333
R4232 a_2148_41600.n5 a_2148_41600.n4 4.63668
R4233 a_2148_41600.n4 a_2148_41600.n0 2.23814
R4234 a_2148_41600.n4 a_2148_41600.n3 0.3305
R4235 a_2148_41600.n1 a_2148_41600.t0 0.20525
R4236 a_2148_41600.n1 a_2148_41600.t1 0.20525
R4237 a_2148_41600.n2 a_2148_41600.t2 0.20525
R4238 a_2148_41600.n2 a_2148_41600.t3 0.20525
R4239 a_2148_41600.n6 a_2148_41600.n5 0.189974
R4240 a_2148_41600.n7 a_2148_41600.t5 0.1643
R4241 a_2148_41600.t6 a_2148_41600.n7 0.1643
R4242 a_2148_41600.n6 a_2148_41600.n0 0.0924286
R4243 a_12148_44200.n2 a_12148_44200.n0 15.3662
R4244 a_12148_44200.n2 a_12148_44200.n1 14.5662
R4245 a_12148_44200.n3 a_12148_44200.n2 7.70696
R4246 a_12148_44200.n3 a_12148_44200.t5 5.9772
R4247 a_12148_44200.t4 a_12148_44200.n3 5.9772
R4248 a_12148_44200.n0 a_12148_44200.t3 0.2735
R4249 a_12148_44200.n0 a_12148_44200.t2 0.2735
R4250 a_12148_44200.n1 a_12148_44200.t1 0.2735
R4251 a_12148_44200.n1 a_12148_44200.t0 0.2735
R4252 a_10548_44200.n2 a_10548_44200.n0 19.8662
R4253 a_10548_44200.n2 a_10548_44200.n1 19.3329
R4254 a_10548_44200.n3 a_10548_44200.n2 11.5875
R4255 a_10548_44200.n3 a_10548_44200.t0 5.9772
R4256 a_10548_44200.t1 a_10548_44200.n3 5.9772
R4257 a_10548_44200.n1 a_10548_44200.t5 0.2735
R4258 a_10548_44200.n1 a_10548_44200.t4 0.2735
R4259 a_10548_44200.n0 a_10548_44200.t3 0.2735
R4260 a_10548_44200.n0 a_10548_44200.t2 0.2735
R4261 a_2548_44200.n2 a_2548_44200.n0 15.3662
R4262 a_2548_44200.n2 a_2548_44200.n1 14.5662
R4263 a_2548_44200.n3 a_2548_44200.n2 7.70696
R4264 a_2548_44200.n3 a_2548_44200.t5 5.9772
R4265 a_2548_44200.t4 a_2548_44200.n3 5.9772
R4266 a_2548_44200.n0 a_2548_44200.t3 0.2735
R4267 a_2548_44200.n0 a_2548_44200.t2 0.2735
R4268 a_2548_44200.n1 a_2548_44200.t1 0.2735
R4269 a_2548_44200.n1 a_2548_44200.t0 0.2735
R4270 a_948_44200.n2 a_948_44200.n0 19.8662
R4271 a_948_44200.n2 a_948_44200.n1 19.3329
R4272 a_948_44200.n3 a_948_44200.n2 11.5875
R4273 a_948_44200.n3 a_948_44200.t5 5.9772
R4274 a_948_44200.t4 a_948_44200.n3 5.9772
R4275 a_948_44200.n1 a_948_44200.t3 0.2735
R4276 a_948_44200.n1 a_948_44200.t2 0.2735
R4277 a_948_44200.n0 a_948_44200.t1 0.2735
R4278 a_948_44200.n0 a_948_44200.t0 0.2735
R4279 XFE_O.NTAIL.n2 XFE_O.NTAIL.n0 20.6105
R4280 XFE_O.NTAIL.n10 XFE_O.NTAIL.n9 18.5365
R4281 XFE_O.NTAIL.n8 XFE_O.NTAIL.n7 10.6141
R4282 XFE_O.NTAIL.n2 XFE_O.NTAIL.n1 10.6141
R4283 XFE_O.NTAIL.n1 XFE_O.NTAIL.t5 5.7796
R4284 XFE_O.NTAIL.n4 XFE_O.NTAIL.t11 5.7796
R4285 XFE_O.NTAIL.n7 XFE_O.NTAIL.t6 5.68486
R4286 XFE_O.NTAIL.n1 XFE_O.NTAIL.t4 5.59012
R4287 XFE_O.NTAIL.n4 XFE_O.NTAIL.n3 5.38537
R4288 XFE_O.NTAIL.n6 XFE_O.NTAIL.n5 5.38537
R4289 XFE_O.NTAIL.n8 XFE_O.NTAIL.n2 2.50485
R4290 XFE_O.NTAIL.n10 XFE_O.NTAIL.n8 1.2918
R4291 XFE_O.NTAIL.n3 XFE_O.NTAIL.t9 0.20525
R4292 XFE_O.NTAIL.n3 XFE_O.NTAIL.t10 0.20525
R4293 XFE_O.NTAIL.n0 XFE_O.NTAIL.t3 0.20525
R4294 XFE_O.NTAIL.n0 XFE_O.NTAIL.t2 0.20525
R4295 XFE_O.NTAIL.n9 XFE_O.NTAIL.t1 0.20525
R4296 XFE_O.NTAIL.n9 XFE_O.NTAIL.t0 0.20525
R4297 XFE_O.NTAIL.n5 XFE_O.NTAIL.t7 0.20525
R4298 XFE_O.NTAIL.n5 XFE_O.NTAIL.t8 0.20525
R4299 XFE_O.NTAIL.n6 XFE_O.NTAIL.n4 0.189974
R4300 XFE_O.NTAIL.n7 XFE_O.NTAIL.n6 0.0952368
R4301 XFE_O.NTAIL XFE_O.NTAIL.n10 0.0396304
R4302 XFE_E.NTAIL.n3 XFE_E.NTAIL.n1 20.6105
R4303 XFE_E.NTAIL XFE_E.NTAIL.n0 18.5757
R4304 XFE_E.NTAIL.n9 XFE_E.NTAIL.n8 10.6141
R4305 XFE_E.NTAIL.n3 XFE_E.NTAIL.n2 10.6141
R4306 XFE_E.NTAIL.n2 XFE_E.NTAIL.t10 5.7796
R4307 XFE_E.NTAIL.n5 XFE_E.NTAIL.t0 5.7796
R4308 XFE_E.NTAIL.n8 XFE_E.NTAIL.t5 5.68486
R4309 XFE_E.NTAIL.n2 XFE_E.NTAIL.t11 5.59012
R4310 XFE_E.NTAIL.n7 XFE_E.NTAIL.n6 5.38537
R4311 XFE_E.NTAIL.n5 XFE_E.NTAIL.n4 5.38537
R4312 XFE_E.NTAIL.n9 XFE_E.NTAIL.n3 2.50485
R4313 XFE_E.NTAIL XFE_E.NTAIL.n9 1.25267
R4314 XFE_E.NTAIL.n0 XFE_E.NTAIL.t9 0.20525
R4315 XFE_E.NTAIL.n0 XFE_E.NTAIL.t8 0.20525
R4316 XFE_E.NTAIL.n1 XFE_E.NTAIL.t7 0.20525
R4317 XFE_E.NTAIL.n1 XFE_E.NTAIL.t6 0.20525
R4318 XFE_E.NTAIL.n6 XFE_E.NTAIL.t3 0.20525
R4319 XFE_E.NTAIL.n6 XFE_E.NTAIL.t4 0.20525
R4320 XFE_E.NTAIL.n4 XFE_E.NTAIL.t1 0.20525
R4321 XFE_E.NTAIL.n4 XFE_E.NTAIL.t2 0.20525
R4322 XFE_E.NTAIL.n7 XFE_E.NTAIL.n5 0.189974
R4323 XFE_E.NTAIL.n8 XFE_E.NTAIL.n7 0.0952368
R4324 XFE_O.BN.n16 XFE_O.BN.t10 113.632
R4325 XFE_O.BN.n2 XFE_O.BN.t23 113.632
R4326 XFE_O.BN.n6 XFE_O.BN.t16 113.632
R4327 XFE_O.BN.n21 XFE_O.BN.t15 109.174
R4328 XFE_O.BN.n20 XFE_O.BN.t14 109.174
R4329 XFE_O.BN.n19 XFE_O.BN.t13 109.174
R4330 XFE_O.BN.n14 XFE_O.BN.t12 109.174
R4331 XFE_O.BN.n15 XFE_O.BN.t11 109.174
R4332 XFE_O.BN.n9 XFE_O.BN.t19 109.174
R4333 XFE_O.BN.n10 XFE_O.BN.t20 109.174
R4334 XFE_O.BN.n3 XFE_O.BN.t22 109.174
R4335 XFE_O.BN.n4 XFE_O.BN.t21 109.174
R4336 XFE_O.BN.n8 XFE_O.BN.t18 109.174
R4337 XFE_O.BN.n5 XFE_O.BN.t17 109.174
R4338 XFE_O.BN.n22 XFE_O.BN.n21 18.4942
R4339 XFE_O.BN.n20 XFE_O.BN.n13 18.4942
R4340 XFE_O.BN.n19 XFE_O.BN.n18 18.4942
R4341 XFE_O.BN.n17 XFE_O.BN.n14 18.4942
R4342 XFE_O.BN.n9 XFE_O.BN.n0 18.4942
R4343 XFE_O.BN.n11 XFE_O.BN.n10 18.4942
R4344 XFE_O.BN.n4 XFE_O.BN.n1 18.4942
R4345 XFE_O.BN.n8 XFE_O.BN.n7 18.4942
R4346 XFE_O.BN.n23 XFE_O.BN.n22 15.5414
R4347 XFE_O.BN.n21 XFE_O.BN.n20 11.6805
R4348 XFE_O.BN.n20 XFE_O.BN.n19 11.6805
R4349 XFE_O.BN.n19 XFE_O.BN.n14 11.6805
R4350 XFE_O.BN.n15 XFE_O.BN.n14 11.6805
R4351 XFE_O.BN.n9 XFE_O.BN.n8 11.6805
R4352 XFE_O.BN.n10 XFE_O.BN.n9 11.6805
R4353 XFE_O.BN.n4 XFE_O.BN.n3 11.6805
R4354 XFE_O.BN.n10 XFE_O.BN.n4 11.6805
R4355 XFE_O.BN.n8 XFE_O.BN.n5 11.6805
R4356 XFE_O.BN.n23 XFE_O.BN.n12 9.87478
R4357 XFE_O.BN.n32 XFE_O.BN.n31 8.36407
R4358 XFE_O.BN.n32 XFE_O.BN.n24 7.91407
R4359 XFE_O.BN.n17 XFE_O.BN.n16 7.17687
R4360 XFE_O.BN.n7 XFE_O.BN.n6 7.17687
R4361 XFE_O.BN.n2 XFE_O.BN.n1 7.17687
R4362 XFE_O.BN.n33 XFE_O.BN.n23 6.41789
R4363 XFE_O.BN.n30 XFE_O.BN.t0 5.7796
R4364 XFE_O.BN.n26 XFE_O.BN.t9 5.7796
R4365 XFE_O.BN.n24 XFE_O.BN.t1 5.73764
R4366 XFE_O.BN.n24 XFE_O.BN.t2 5.54817
R4367 XFE_O.BN.n26 XFE_O.BN.n25 5.38537
R4368 XFE_O.BN.n28 XFE_O.BN.n27 5.38537
R4369 XFE_O.BN.n30 XFE_O.BN.n29 5.38537
R4370 XFE_O.BN.n33 XFE_O.BN.n32 4.5005
R4371 XFE_O.BN.n16 XFE_O.BN.n15 4.42851
R4372 XFE_O.BN.n3 XFE_O.BN.n2 4.42851
R4373 XFE_O.BN.n6 XFE_O.BN.n5 4.42851
R4374 XFE_O.BN.n25 XFE_O.BN.t4 0.20525
R4375 XFE_O.BN.n25 XFE_O.BN.t3 0.20525
R4376 XFE_O.BN.n27 XFE_O.BN.t6 0.20525
R4377 XFE_O.BN.n27 XFE_O.BN.t5 0.20525
R4378 XFE_O.BN.n29 XFE_O.BN.t8 0.20525
R4379 XFE_O.BN.n29 XFE_O.BN.t7 0.20525
R4380 XFE_O.BN.n28 XFE_O.BN.n26 0.189974
R4381 XFE_O.BN.n22 XFE_O.BN.n13 0.1205
R4382 XFE_O.BN.n18 XFE_O.BN.n13 0.1205
R4383 XFE_O.BN.n18 XFE_O.BN.n17 0.1205
R4384 XFE_O.BN.n7 XFE_O.BN.n0 0.1205
R4385 XFE_O.BN.n11 XFE_O.BN.n1 0.1205
R4386 XFE_O.BN.n31 XFE_O.BN.n30 0.0952368
R4387 XFE_O.BN.n31 XFE_O.BN.n28 0.0952368
R4388 XFE_O.BN.n12 XFE_O.BN.n0 0.0485
R4389 XFE_O.BN.n12 XFE_O.BN.n11 0.0485
R4390 XFE_O.BN XFE_O.BN.n33 0.0396304
R4391 XFE_O.SXN.n3 XFE_O.SXN.t19 113.632
R4392 XFE_O.SXN.n7 XFE_O.SXN.t12 113.632
R4393 XFE_O.SXN.n0 XFE_O.SXN.t20 113.618
R4394 XFE_O.SXN.n0 XFE_O.SXN.t21 113.618
R4395 XFE_O.SXN.n10 XFE_O.SXN.t15 109.174
R4396 XFE_O.SXN.n11 XFE_O.SXN.t16 109.174
R4397 XFE_O.SXN.n4 XFE_O.SXN.t18 109.174
R4398 XFE_O.SXN.n5 XFE_O.SXN.t17 109.174
R4399 XFE_O.SXN.n9 XFE_O.SXN.t14 109.174
R4400 XFE_O.SXN.n6 XFE_O.SXN.t13 109.174
R4401 XFE_O.SXN.n14 XFE_O.SXN.n0 21.4356
R4402 XFE_O.SXN.n10 XFE_O.SXN.n1 18.4942
R4403 XFE_O.SXN.n12 XFE_O.SXN.n11 18.4942
R4404 XFE_O.SXN.n5 XFE_O.SXN.n2 18.4942
R4405 XFE_O.SXN.n9 XFE_O.SXN.n8 18.4942
R4406 XFE_O.SXN.n26 XFE_O.SXN.n25 17.1983
R4407 XFE_O.SXN.n18 XFE_O.SXN.n17 12.7558
R4408 XFE_O.SXN.n10 XFE_O.SXN.n9 11.6805
R4409 XFE_O.SXN.n11 XFE_O.SXN.n10 11.6805
R4410 XFE_O.SXN.n5 XFE_O.SXN.n4 11.6805
R4411 XFE_O.SXN.n11 XFE_O.SXN.n5 11.6805
R4412 XFE_O.SXN.n9 XFE_O.SXN.n6 11.6805
R4413 XFE_O.SXN.n18 XFE_O.SXN.n14 11.3092
R4414 XFE_O.SXN.n14 XFE_O.SXN.n13 10.9034
R4415 XFE_O.SXN.n8 XFE_O.SXN.n7 7.17687
R4416 XFE_O.SXN.n3 XFE_O.SXN.n2 7.17687
R4417 XFE_O.SXN.n16 XFE_O.SXN.t9 5.7796
R4418 XFE_O.SXN.n20 XFE_O.SXN.t11 5.73764
R4419 XFE_O.SXN.n17 XFE_O.SXN.t2 5.59012
R4420 XFE_O.SXN.n25 XFE_O.SXN.t10 5.54817
R4421 XFE_O.SXN.n16 XFE_O.SXN.n15 5.38537
R4422 XFE_O.SXN.n24 XFE_O.SXN.n23 5.32067
R4423 XFE_O.SXN.n22 XFE_O.SXN.n21 5.32067
R4424 XFE_O.SXN.n20 XFE_O.SXN.n19 5.32067
R4425 XFE_O.SXN.n4 XFE_O.SXN.n3 4.42851
R4426 XFE_O.SXN.n7 XFE_O.SXN.n6 4.42851
R4427 XFE_O.SXN.n26 XFE_O.SXN.n18 0.313543
R4428 XFE_O.SXN.n23 XFE_O.SXN.t6 0.228
R4429 XFE_O.SXN.n23 XFE_O.SXN.t5 0.228
R4430 XFE_O.SXN.n21 XFE_O.SXN.t4 0.228
R4431 XFE_O.SXN.n21 XFE_O.SXN.t3 0.228
R4432 XFE_O.SXN.n19 XFE_O.SXN.t8 0.228
R4433 XFE_O.SXN.n19 XFE_O.SXN.t7 0.228
R4434 XFE_O.SXN.n15 XFE_O.SXN.t1 0.20525
R4435 XFE_O.SXN.n15 XFE_O.SXN.t0 0.20525
R4436 XFE_O.SXN.n17 XFE_O.SXN.n16 0.189974
R4437 XFE_O.SXN.n22 XFE_O.SXN.n20 0.189974
R4438 XFE_O.SXN.n24 XFE_O.SXN.n22 0.189974
R4439 XFE_O.SXN.n25 XFE_O.SXN.n24 0.189974
R4440 XFE_O.SXN.n8 XFE_O.SXN.n1 0.1205
R4441 XFE_O.SXN.n12 XFE_O.SXN.n2 0.1205
R4442 XFE_O.SXN.n13 XFE_O.SXN.n1 0.0485
R4443 XFE_O.SXN.n13 XFE_O.SXN.n12 0.0485
R4444 XFE_O.SXN XFE_O.SXN.n26 0.0396304
R4445 XFE_O.SXP.n14 XFE_O.SXP.t19 113.632
R4446 XFE_O.SXP.n18 XFE_O.SXP.t12 113.632
R4447 XFE_O.SXP.n11 XFE_O.SXP.t20 113.618
R4448 XFE_O.SXP.n11 XFE_O.SXP.t21 113.618
R4449 XFE_O.SXP.n21 XFE_O.SXP.t15 109.174
R4450 XFE_O.SXP.n22 XFE_O.SXP.t16 109.174
R4451 XFE_O.SXP.n15 XFE_O.SXP.t18 109.174
R4452 XFE_O.SXP.n16 XFE_O.SXP.t17 109.174
R4453 XFE_O.SXP.n20 XFE_O.SXP.t14 109.174
R4454 XFE_O.SXP.n17 XFE_O.SXP.t13 109.174
R4455 XFE_O.SXP.n25 XFE_O.SXP.n11 21.8856
R4456 XFE_O.SXP.n21 XFE_O.SXP.n12 18.4942
R4457 XFE_O.SXP.n23 XFE_O.SXP.n22 18.4942
R4458 XFE_O.SXP.n16 XFE_O.SXP.n13 18.4942
R4459 XFE_O.SXP.n20 XFE_O.SXP.n19 18.4942
R4460 XFE_O.SXP.n26 XFE_O.SXP.n10 15.1644
R4461 XFE_O.SXP.n21 XFE_O.SXP.n20 11.6805
R4462 XFE_O.SXP.n22 XFE_O.SXP.n21 11.6805
R4463 XFE_O.SXP.n16 XFE_O.SXP.n15 11.6805
R4464 XFE_O.SXP.n22 XFE_O.SXP.n16 11.6805
R4465 XFE_O.SXP.n20 XFE_O.SXP.n17 11.6805
R4466 XFE_O.SXP.n25 XFE_O.SXP.n24 10.4534
R4467 XFE_O.SXP.n10 XFE_O.SXP.n6 9.54828
R4468 XFE_O.SXP.n19 XFE_O.SXP.n18 7.17687
R4469 XFE_O.SXP.n14 XFE_O.SXP.n13 7.17687
R4470 XFE_O.SXP.n8 XFE_O.SXP.t7 5.7796
R4471 XFE_O.SXP.n1 XFE_O.SXP.t11 5.73764
R4472 XFE_O.SXP.n9 XFE_O.SXP.t10 5.59012
R4473 XFE_O.SXP.n6 XFE_O.SXP.t0 5.54817
R4474 XFE_O.SXP.n8 XFE_O.SXP.n7 5.38537
R4475 XFE_O.SXP.n1 XFE_O.SXP.n0 5.32067
R4476 XFE_O.SXP.n3 XFE_O.SXP.n2 5.32067
R4477 XFE_O.SXP.n5 XFE_O.SXP.n4 5.32067
R4478 XFE_O.SXP.n10 XFE_O.SXP.n9 4.97418
R4479 XFE_O.SXP.n26 XFE_O.SXP.n25 4.5005
R4480 XFE_O.SXP.n15 XFE_O.SXP.n14 4.42851
R4481 XFE_O.SXP.n18 XFE_O.SXP.n17 4.42851
R4482 XFE_O.SXP.n0 XFE_O.SXP.t9 0.228
R4483 XFE_O.SXP.n0 XFE_O.SXP.t8 0.228
R4484 XFE_O.SXP.n2 XFE_O.SXP.t4 0.228
R4485 XFE_O.SXP.n2 XFE_O.SXP.t3 0.228
R4486 XFE_O.SXP.n4 XFE_O.SXP.t2 0.228
R4487 XFE_O.SXP.n4 XFE_O.SXP.t1 0.228
R4488 XFE_O.SXP.n7 XFE_O.SXP.t6 0.20525
R4489 XFE_O.SXP.n7 XFE_O.SXP.t5 0.20525
R4490 XFE_O.SXP.n6 XFE_O.SXP.n5 0.189974
R4491 XFE_O.SXP.n5 XFE_O.SXP.n3 0.189974
R4492 XFE_O.SXP.n3 XFE_O.SXP.n1 0.189974
R4493 XFE_O.SXP.n9 XFE_O.SXP.n8 0.189974
R4494 XFE_O.SXP.n19 XFE_O.SXP.n12 0.1205
R4495 XFE_O.SXP.n23 XFE_O.SXP.n13 0.1205
R4496 XFE_O.SXP.n24 XFE_O.SXP.n12 0.0485
R4497 XFE_O.SXP.n24 XFE_O.SXP.n23 0.0485
R4498 XFE_O.SXP XFE_O.SXP.n26 0.0396304
R4499 XFE_O.BP.n25 XFE_O.BP.t15 113.632
R4500 XFE_O.BP.n11 XFE_O.BP.t23 113.632
R4501 XFE_O.BP.n15 XFE_O.BP.t16 113.632
R4502 XFE_O.BP.n26 XFE_O.BP.t14 109.174
R4503 XFE_O.BP.n27 XFE_O.BP.t13 109.174
R4504 XFE_O.BP.n28 XFE_O.BP.t12 109.174
R4505 XFE_O.BP.n29 XFE_O.BP.t11 109.174
R4506 XFE_O.BP.n30 XFE_O.BP.t10 109.174
R4507 XFE_O.BP.n18 XFE_O.BP.t19 109.174
R4508 XFE_O.BP.n19 XFE_O.BP.t20 109.174
R4509 XFE_O.BP.n12 XFE_O.BP.t22 109.174
R4510 XFE_O.BP.n13 XFE_O.BP.t21 109.174
R4511 XFE_O.BP.n17 XFE_O.BP.t18 109.174
R4512 XFE_O.BP.n14 XFE_O.BP.t17 109.174
R4513 XFE_O.BP.n27 XFE_O.BP.n24 18.4942
R4514 XFE_O.BP.n28 XFE_O.BP.n23 18.4942
R4515 XFE_O.BP.n29 XFE_O.BP.n22 18.4942
R4516 XFE_O.BP.n31 XFE_O.BP.n30 18.4942
R4517 XFE_O.BP.n18 XFE_O.BP.n9 18.4942
R4518 XFE_O.BP.n20 XFE_O.BP.n19 18.4942
R4519 XFE_O.BP.n13 XFE_O.BP.n10 18.4942
R4520 XFE_O.BP.n17 XFE_O.BP.n16 18.4942
R4521 XFE_O.BP.n32 XFE_O.BP.n31 15.0914
R4522 XFE_O.BP.n27 XFE_O.BP.n26 11.6805
R4523 XFE_O.BP.n28 XFE_O.BP.n27 11.6805
R4524 XFE_O.BP.n29 XFE_O.BP.n28 11.6805
R4525 XFE_O.BP.n30 XFE_O.BP.n29 11.6805
R4526 XFE_O.BP.n18 XFE_O.BP.n17 11.6805
R4527 XFE_O.BP.n19 XFE_O.BP.n18 11.6805
R4528 XFE_O.BP.n13 XFE_O.BP.n12 11.6805
R4529 XFE_O.BP.n19 XFE_O.BP.n13 11.6805
R4530 XFE_O.BP.n17 XFE_O.BP.n14 11.6805
R4531 XFE_O.BP.n32 XFE_O.BP.n21 10.3248
R4532 XFE_O.BP.n8 XFE_O.BP.n0 8.36407
R4533 XFE_O.BP.n8 XFE_O.BP.n7 7.91407
R4534 XFE_O.BP.n25 XFE_O.BP.n24 7.17687
R4535 XFE_O.BP.n16 XFE_O.BP.n15 7.17687
R4536 XFE_O.BP.n11 XFE_O.BP.n10 7.17687
R4537 XFE_O.BP.n33 XFE_O.BP.n8 6.10485
R4538 XFE_O.BP.n2 XFE_O.BP.t9 5.7796
R4539 XFE_O.BP.n6 XFE_O.BP.t2 5.7796
R4540 XFE_O.BP.n0 XFE_O.BP.t1 5.73764
R4541 XFE_O.BP.n0 XFE_O.BP.t0 5.54817
R4542 XFE_O.BP.n2 XFE_O.BP.n1 5.38537
R4543 XFE_O.BP.n4 XFE_O.BP.n3 5.38537
R4544 XFE_O.BP.n6 XFE_O.BP.n5 5.38537
R4545 XFE_O.BP.n33 XFE_O.BP.n32 4.5005
R4546 XFE_O.BP.n26 XFE_O.BP.n25 4.42851
R4547 XFE_O.BP.n12 XFE_O.BP.n11 4.42851
R4548 XFE_O.BP.n15 XFE_O.BP.n14 4.42851
R4549 XFE_O.BP.n1 XFE_O.BP.t7 0.20525
R4550 XFE_O.BP.n1 XFE_O.BP.t8 0.20525
R4551 XFE_O.BP.n3 XFE_O.BP.t5 0.20525
R4552 XFE_O.BP.n3 XFE_O.BP.t6 0.20525
R4553 XFE_O.BP.n5 XFE_O.BP.t3 0.20525
R4554 XFE_O.BP.n5 XFE_O.BP.t4 0.20525
R4555 XFE_O.BP.n4 XFE_O.BP.n2 0.189974
R4556 XFE_O.BP.n24 XFE_O.BP.n23 0.1205
R4557 XFE_O.BP.n23 XFE_O.BP.n22 0.1205
R4558 XFE_O.BP.n31 XFE_O.BP.n22 0.1205
R4559 XFE_O.BP.n16 XFE_O.BP.n9 0.1205
R4560 XFE_O.BP.n20 XFE_O.BP.n10 0.1205
R4561 XFE_O.BP.n7 XFE_O.BP.n6 0.0952368
R4562 XFE_O.BP.n7 XFE_O.BP.n4 0.0952368
R4563 XFE_O.BP.n21 XFE_O.BP.n9 0.0485
R4564 XFE_O.BP.n21 XFE_O.BP.n20 0.0485
R4565 XFE_O.BP XFE_O.BP.n33 0.0396304
R4566 XFE_E.BP.n16 XFE_E.BP.t10 113.632
R4567 XFE_E.BP.n2 XFE_E.BP.t23 113.632
R4568 XFE_E.BP.n6 XFE_E.BP.t16 113.632
R4569 XFE_E.BP.n21 XFE_E.BP.t15 109.174
R4570 XFE_E.BP.n20 XFE_E.BP.t14 109.174
R4571 XFE_E.BP.n19 XFE_E.BP.t13 109.174
R4572 XFE_E.BP.n14 XFE_E.BP.t12 109.174
R4573 XFE_E.BP.n15 XFE_E.BP.t11 109.174
R4574 XFE_E.BP.n9 XFE_E.BP.t19 109.174
R4575 XFE_E.BP.n10 XFE_E.BP.t20 109.174
R4576 XFE_E.BP.n3 XFE_E.BP.t22 109.174
R4577 XFE_E.BP.n4 XFE_E.BP.t21 109.174
R4578 XFE_E.BP.n8 XFE_E.BP.t18 109.174
R4579 XFE_E.BP.n5 XFE_E.BP.t17 109.174
R4580 XFE_E.BP.n22 XFE_E.BP.n21 18.4942
R4581 XFE_E.BP.n20 XFE_E.BP.n13 18.4942
R4582 XFE_E.BP.n19 XFE_E.BP.n18 18.4942
R4583 XFE_E.BP.n17 XFE_E.BP.n14 18.4942
R4584 XFE_E.BP.n9 XFE_E.BP.n0 18.4942
R4585 XFE_E.BP.n11 XFE_E.BP.n10 18.4942
R4586 XFE_E.BP.n4 XFE_E.BP.n1 18.4942
R4587 XFE_E.BP.n8 XFE_E.BP.n7 18.4942
R4588 XFE_E.BP.n23 XFE_E.BP.n22 15.0914
R4589 XFE_E.BP.n21 XFE_E.BP.n20 11.6805
R4590 XFE_E.BP.n20 XFE_E.BP.n19 11.6805
R4591 XFE_E.BP.n19 XFE_E.BP.n14 11.6805
R4592 XFE_E.BP.n15 XFE_E.BP.n14 11.6805
R4593 XFE_E.BP.n9 XFE_E.BP.n8 11.6805
R4594 XFE_E.BP.n10 XFE_E.BP.n9 11.6805
R4595 XFE_E.BP.n4 XFE_E.BP.n3 11.6805
R4596 XFE_E.BP.n10 XFE_E.BP.n4 11.6805
R4597 XFE_E.BP.n8 XFE_E.BP.n5 11.6805
R4598 XFE_E.BP.n23 XFE_E.BP.n12 10.3248
R4599 XFE_E.BP.n32 XFE_E.BP.n24 8.36407
R4600 XFE_E.BP.n32 XFE_E.BP.n31 7.91407
R4601 XFE_E.BP.n17 XFE_E.BP.n16 7.17687
R4602 XFE_E.BP.n7 XFE_E.BP.n6 7.17687
R4603 XFE_E.BP.n2 XFE_E.BP.n1 7.17687
R4604 XFE_E.BP XFE_E.BP.n32 6.06572
R4605 XFE_E.BP.n26 XFE_E.BP.t0 5.7796
R4606 XFE_E.BP.n28 XFE_E.BP.t8 5.7796
R4607 XFE_E.BP.n24 XFE_E.BP.t3 5.73764
R4608 XFE_E.BP.n24 XFE_E.BP.t9 5.54817
R4609 XFE_E.BP.n26 XFE_E.BP.n25 5.38537
R4610 XFE_E.BP.n30 XFE_E.BP.n29 5.38537
R4611 XFE_E.BP.n28 XFE_E.BP.n27 5.38537
R4612 XFE_E.BP XFE_E.BP.n23 4.53963
R4613 XFE_E.BP.n16 XFE_E.BP.n15 4.42851
R4614 XFE_E.BP.n3 XFE_E.BP.n2 4.42851
R4615 XFE_E.BP.n6 XFE_E.BP.n5 4.42851
R4616 XFE_E.BP.n25 XFE_E.BP.t2 0.20525
R4617 XFE_E.BP.n25 XFE_E.BP.t1 0.20525
R4618 XFE_E.BP.n29 XFE_E.BP.t5 0.20525
R4619 XFE_E.BP.n29 XFE_E.BP.t4 0.20525
R4620 XFE_E.BP.n27 XFE_E.BP.t7 0.20525
R4621 XFE_E.BP.n27 XFE_E.BP.t6 0.20525
R4622 XFE_E.BP.n30 XFE_E.BP.n28 0.189974
R4623 XFE_E.BP.n22 XFE_E.BP.n13 0.1205
R4624 XFE_E.BP.n18 XFE_E.BP.n13 0.1205
R4625 XFE_E.BP.n18 XFE_E.BP.n17 0.1205
R4626 XFE_E.BP.n7 XFE_E.BP.n0 0.1205
R4627 XFE_E.BP.n11 XFE_E.BP.n1 0.1205
R4628 XFE_E.BP.n31 XFE_E.BP.n30 0.0952368
R4629 XFE_E.BP.n31 XFE_E.BP.n26 0.0952368
R4630 XFE_E.BP.n12 XFE_E.BP.n0 0.0485
R4631 XFE_E.BP.n12 XFE_E.BP.n11 0.0485
R4632 XFE_E.SXP.n3 XFE_E.SXP.t19 113.632
R4633 XFE_E.SXP.n7 XFE_E.SXP.t12 113.632
R4634 XFE_E.SXP.n0 XFE_E.SXP.t20 113.618
R4635 XFE_E.SXP.n0 XFE_E.SXP.t21 113.618
R4636 XFE_E.SXP.n10 XFE_E.SXP.t15 109.174
R4637 XFE_E.SXP.n11 XFE_E.SXP.t16 109.174
R4638 XFE_E.SXP.n4 XFE_E.SXP.t18 109.174
R4639 XFE_E.SXP.n5 XFE_E.SXP.t17 109.174
R4640 XFE_E.SXP.n9 XFE_E.SXP.t14 109.174
R4641 XFE_E.SXP.n6 XFE_E.SXP.t13 109.174
R4642 XFE_E.SXP.n14 XFE_E.SXP.n0 21.8856
R4643 XFE_E.SXP.n10 XFE_E.SXP.n1 18.4942
R4644 XFE_E.SXP.n12 XFE_E.SXP.n11 18.4942
R4645 XFE_E.SXP.n5 XFE_E.SXP.n2 18.4942
R4646 XFE_E.SXP.n9 XFE_E.SXP.n8 18.4942
R4647 XFE_E.SXP XFE_E.SXP.n25 15.1253
R4648 XFE_E.SXP.n10 XFE_E.SXP.n9 11.6805
R4649 XFE_E.SXP.n11 XFE_E.SXP.n10 11.6805
R4650 XFE_E.SXP.n5 XFE_E.SXP.n4 11.6805
R4651 XFE_E.SXP.n11 XFE_E.SXP.n5 11.6805
R4652 XFE_E.SXP.n9 XFE_E.SXP.n6 11.6805
R4653 XFE_E.SXP.n14 XFE_E.SXP.n13 10.4534
R4654 XFE_E.SXP.n25 XFE_E.SXP.n21 9.54828
R4655 XFE_E.SXP.n8 XFE_E.SXP.n7 7.17687
R4656 XFE_E.SXP.n3 XFE_E.SXP.n2 7.17687
R4657 XFE_E.SXP.n23 XFE_E.SXP.t3 5.7796
R4658 XFE_E.SXP.n16 XFE_E.SXP.t11 5.73764
R4659 XFE_E.SXP.n24 XFE_E.SXP.t0 5.59012
R4660 XFE_E.SXP.n21 XFE_E.SXP.t4 5.54817
R4661 XFE_E.SXP.n23 XFE_E.SXP.n22 5.38537
R4662 XFE_E.SXP.n20 XFE_E.SXP.n19 5.32067
R4663 XFE_E.SXP.n18 XFE_E.SXP.n17 5.32067
R4664 XFE_E.SXP.n16 XFE_E.SXP.n15 5.32067
R4665 XFE_E.SXP.n25 XFE_E.SXP.n24 4.97418
R4666 XFE_E.SXP XFE_E.SXP.n14 4.53963
R4667 XFE_E.SXP.n4 XFE_E.SXP.n3 4.42851
R4668 XFE_E.SXP.n7 XFE_E.SXP.n6 4.42851
R4669 XFE_E.SXP.n19 XFE_E.SXP.t6 0.228
R4670 XFE_E.SXP.n19 XFE_E.SXP.t5 0.228
R4671 XFE_E.SXP.n17 XFE_E.SXP.t8 0.228
R4672 XFE_E.SXP.n17 XFE_E.SXP.t7 0.228
R4673 XFE_E.SXP.n15 XFE_E.SXP.t10 0.228
R4674 XFE_E.SXP.n15 XFE_E.SXP.t9 0.228
R4675 XFE_E.SXP.n22 XFE_E.SXP.t2 0.20525
R4676 XFE_E.SXP.n22 XFE_E.SXP.t1 0.20525
R4677 XFE_E.SXP.n24 XFE_E.SXP.n23 0.189974
R4678 XFE_E.SXP.n18 XFE_E.SXP.n16 0.189974
R4679 XFE_E.SXP.n20 XFE_E.SXP.n18 0.189974
R4680 XFE_E.SXP.n21 XFE_E.SXP.n20 0.189974
R4681 XFE_E.SXP.n8 XFE_E.SXP.n1 0.1205
R4682 XFE_E.SXP.n12 XFE_E.SXP.n2 0.1205
R4683 XFE_E.SXP.n13 XFE_E.SXP.n1 0.0485
R4684 XFE_E.SXP.n13 XFE_E.SXP.n12 0.0485
R4685 XFE_E.SXN.n10 XFE_E.SXN.t19 113.632
R4686 XFE_E.SXN.n14 XFE_E.SXN.t12 113.632
R4687 XFE_E.SXN.n7 XFE_E.SXN.t20 113.618
R4688 XFE_E.SXN.n7 XFE_E.SXN.t21 113.618
R4689 XFE_E.SXN.n17 XFE_E.SXN.t15 109.174
R4690 XFE_E.SXN.n18 XFE_E.SXN.t16 109.174
R4691 XFE_E.SXN.n11 XFE_E.SXN.t18 109.174
R4692 XFE_E.SXN.n12 XFE_E.SXN.t17 109.174
R4693 XFE_E.SXN.n16 XFE_E.SXN.t14 109.174
R4694 XFE_E.SXN.n13 XFE_E.SXN.t13 109.174
R4695 XFE_E.SXN.n21 XFE_E.SXN.n7 21.4356
R4696 XFE_E.SXN.n17 XFE_E.SXN.n8 18.4942
R4697 XFE_E.SXN.n19 XFE_E.SXN.n18 18.4942
R4698 XFE_E.SXN.n12 XFE_E.SXN.n9 18.4942
R4699 XFE_E.SXN.n16 XFE_E.SXN.n15 18.4942
R4700 XFE_E.SXN XFE_E.SXN.n6 17.2374
R4701 XFE_E.SXN.n25 XFE_E.SXN.n24 12.7558
R4702 XFE_E.SXN.n17 XFE_E.SXN.n16 11.6805
R4703 XFE_E.SXN.n18 XFE_E.SXN.n17 11.6805
R4704 XFE_E.SXN.n12 XFE_E.SXN.n11 11.6805
R4705 XFE_E.SXN.n18 XFE_E.SXN.n12 11.6805
R4706 XFE_E.SXN.n16 XFE_E.SXN.n13 11.6805
R4707 XFE_E.SXN.n25 XFE_E.SXN.n21 11.3092
R4708 XFE_E.SXN.n21 XFE_E.SXN.n20 10.9034
R4709 XFE_E.SXN.n15 XFE_E.SXN.n14 7.17687
R4710 XFE_E.SXN.n10 XFE_E.SXN.n9 7.17687
R4711 XFE_E.SXN.n23 XFE_E.SXN.t9 5.7796
R4712 XFE_E.SXN.n1 XFE_E.SXN.t8 5.73764
R4713 XFE_E.SXN.n24 XFE_E.SXN.t0 5.59012
R4714 XFE_E.SXN.n6 XFE_E.SXN.t2 5.54817
R4715 XFE_E.SXN.n23 XFE_E.SXN.n22 5.38537
R4716 XFE_E.SXN.n1 XFE_E.SXN.n0 5.32067
R4717 XFE_E.SXN.n3 XFE_E.SXN.n2 5.32067
R4718 XFE_E.SXN.n5 XFE_E.SXN.n4 5.32067
R4719 XFE_E.SXN.n11 XFE_E.SXN.n10 4.42851
R4720 XFE_E.SXN.n14 XFE_E.SXN.n13 4.42851
R4721 XFE_E.SXN XFE_E.SXN.n25 0.274413
R4722 XFE_E.SXN.n0 XFE_E.SXN.t6 0.228
R4723 XFE_E.SXN.n0 XFE_E.SXN.t11 0.228
R4724 XFE_E.SXN.n2 XFE_E.SXN.t5 0.228
R4725 XFE_E.SXN.n2 XFE_E.SXN.t3 0.228
R4726 XFE_E.SXN.n4 XFE_E.SXN.t7 0.228
R4727 XFE_E.SXN.n4 XFE_E.SXN.t1 0.228
R4728 XFE_E.SXN.n22 XFE_E.SXN.t4 0.20525
R4729 XFE_E.SXN.n22 XFE_E.SXN.t10 0.20525
R4730 XFE_E.SXN.n24 XFE_E.SXN.n23 0.189974
R4731 XFE_E.SXN.n6 XFE_E.SXN.n5 0.189974
R4732 XFE_E.SXN.n5 XFE_E.SXN.n3 0.189974
R4733 XFE_E.SXN.n3 XFE_E.SXN.n1 0.189974
R4734 XFE_E.SXN.n15 XFE_E.SXN.n8 0.1205
R4735 XFE_E.SXN.n19 XFE_E.SXN.n9 0.1205
R4736 XFE_E.SXN.n20 XFE_E.SXN.n8 0.0485
R4737 XFE_E.SXN.n20 XFE_E.SXN.n19 0.0485
R4738 XFE_E.BN.n25 XFE_E.BN.t15 113.632
R4739 XFE_E.BN.n11 XFE_E.BN.t23 113.632
R4740 XFE_E.BN.n15 XFE_E.BN.t16 113.632
R4741 XFE_E.BN.n26 XFE_E.BN.t14 109.174
R4742 XFE_E.BN.n27 XFE_E.BN.t13 109.174
R4743 XFE_E.BN.n28 XFE_E.BN.t12 109.174
R4744 XFE_E.BN.n29 XFE_E.BN.t11 109.174
R4745 XFE_E.BN.n30 XFE_E.BN.t10 109.174
R4746 XFE_E.BN.n18 XFE_E.BN.t19 109.174
R4747 XFE_E.BN.n19 XFE_E.BN.t20 109.174
R4748 XFE_E.BN.n12 XFE_E.BN.t22 109.174
R4749 XFE_E.BN.n13 XFE_E.BN.t21 109.174
R4750 XFE_E.BN.n17 XFE_E.BN.t18 109.174
R4751 XFE_E.BN.n14 XFE_E.BN.t17 109.174
R4752 XFE_E.BN.n27 XFE_E.BN.n24 18.4942
R4753 XFE_E.BN.n28 XFE_E.BN.n23 18.4942
R4754 XFE_E.BN.n29 XFE_E.BN.n22 18.4942
R4755 XFE_E.BN.n31 XFE_E.BN.n30 18.4942
R4756 XFE_E.BN.n18 XFE_E.BN.n9 18.4942
R4757 XFE_E.BN.n20 XFE_E.BN.n19 18.4942
R4758 XFE_E.BN.n13 XFE_E.BN.n10 18.4942
R4759 XFE_E.BN.n17 XFE_E.BN.n16 18.4942
R4760 XFE_E.BN.n32 XFE_E.BN.n31 15.5414
R4761 XFE_E.BN.n27 XFE_E.BN.n26 11.6805
R4762 XFE_E.BN.n28 XFE_E.BN.n27 11.6805
R4763 XFE_E.BN.n29 XFE_E.BN.n28 11.6805
R4764 XFE_E.BN.n30 XFE_E.BN.n29 11.6805
R4765 XFE_E.BN.n18 XFE_E.BN.n17 11.6805
R4766 XFE_E.BN.n19 XFE_E.BN.n18 11.6805
R4767 XFE_E.BN.n13 XFE_E.BN.n12 11.6805
R4768 XFE_E.BN.n19 XFE_E.BN.n13 11.6805
R4769 XFE_E.BN.n17 XFE_E.BN.n14 11.6805
R4770 XFE_E.BN.n32 XFE_E.BN.n21 9.87478
R4771 XFE_E.BN.n8 XFE_E.BN.n7 8.36407
R4772 XFE_E.BN.n8 XFE_E.BN.n0 7.91407
R4773 XFE_E.BN.n25 XFE_E.BN.n24 7.17687
R4774 XFE_E.BN.n16 XFE_E.BN.n15 7.17687
R4775 XFE_E.BN.n11 XFE_E.BN.n10 7.17687
R4776 XFE_E.BN XFE_E.BN.n32 6.37876
R4777 XFE_E.BN.n2 XFE_E.BN.t9 5.7796
R4778 XFE_E.BN.n4 XFE_E.BN.t2 5.7796
R4779 XFE_E.BN.n0 XFE_E.BN.t0 5.73764
R4780 XFE_E.BN.n0 XFE_E.BN.t1 5.54817
R4781 XFE_E.BN.n2 XFE_E.BN.n1 5.38537
R4782 XFE_E.BN.n6 XFE_E.BN.n5 5.38537
R4783 XFE_E.BN.n4 XFE_E.BN.n3 5.38537
R4784 XFE_E.BN XFE_E.BN.n8 4.53963
R4785 XFE_E.BN.n26 XFE_E.BN.n25 4.42851
R4786 XFE_E.BN.n12 XFE_E.BN.n11 4.42851
R4787 XFE_E.BN.n15 XFE_E.BN.n14 4.42851
R4788 XFE_E.BN.n1 XFE_E.BN.t7 0.20525
R4789 XFE_E.BN.n1 XFE_E.BN.t8 0.20525
R4790 XFE_E.BN.n5 XFE_E.BN.t5 0.20525
R4791 XFE_E.BN.n5 XFE_E.BN.t6 0.20525
R4792 XFE_E.BN.n3 XFE_E.BN.t3 0.20525
R4793 XFE_E.BN.n3 XFE_E.BN.t4 0.20525
R4794 XFE_E.BN.n6 XFE_E.BN.n4 0.189974
R4795 XFE_E.BN.n24 XFE_E.BN.n23 0.1205
R4796 XFE_E.BN.n23 XFE_E.BN.n22 0.1205
R4797 XFE_E.BN.n31 XFE_E.BN.n22 0.1205
R4798 XFE_E.BN.n16 XFE_E.BN.n9 0.1205
R4799 XFE_E.BN.n20 XFE_E.BN.n10 0.1205
R4800 XFE_E.BN.n7 XFE_E.BN.n6 0.0952368
R4801 XFE_E.BN.n7 XFE_E.BN.n2 0.0952368
R4802 XFE_E.BN.n21 XFE_E.BN.n9 0.0485
R4803 XFE_E.BN.n21 XFE_E.BN.n20 0.0485
R4804 XFE_O.NREGEN.n7 XFE_O.NREGEN.n0 18.0069
R4805 XFE_O.NREGEN.n29 XFE_O.NREGEN.n22 18.0069
R4806 XFE_O.NREGEN.n10 XFE_O.NREGEN.n9 10.6614
R4807 XFE_O.NREGEN.n21 XFE_O.NREGEN.n20 10.6614
R4808 XFE_O.NREGEN.n18 XFE_O.NREGEN.n17 9.32836
R4809 XFE_O.NREGEN.n7 XFE_O.NREGEN.n6 6.11407
R4810 XFE_O.NREGEN.n29 XFE_O.NREGEN.n28 6.11407
R4811 XFE_O.NREGEN.n10 XFE_O.NREGEN.n7 6.10485
R4812 XFE_O.NREGEN.n12 XFE_O.NREGEN.t27 5.7796
R4813 XFE_O.NREGEN.n16 XFE_O.NREGEN.t20 5.7796
R4814 XFE_O.NREGEN.n18 XFE_O.NREGEN.n10 5.75267
R4815 XFE_O.NREGEN.n0 XFE_O.NREGEN.t18 5.73764
R4816 XFE_O.NREGEN.n22 XFE_O.NREGEN.t16 5.73764
R4817 XFE_O.NREGEN.n9 XFE_O.NREGEN.t32 5.59012
R4818 XFE_O.NREGEN.n20 XFE_O.NREGEN.t10 5.59012
R4819 XFE_O.NREGEN.n9 XFE_O.NREGEN.n8 5.57485
R4820 XFE_O.NREGEN.n20 XFE_O.NREGEN.n19 5.57485
R4821 XFE_O.NREGEN.n6 XFE_O.NREGEN.n1 5.57485
R4822 XFE_O.NREGEN.n5 XFE_O.NREGEN.n3 5.57485
R4823 XFE_O.NREGEN.n28 XFE_O.NREGEN.n23 5.57485
R4824 XFE_O.NREGEN.n27 XFE_O.NREGEN.n25 5.57485
R4825 XFE_O.NREGEN.n0 XFE_O.NREGEN.t19 5.54817
R4826 XFE_O.NREGEN.n22 XFE_O.NREGEN.t17 5.54817
R4827 XFE_O.NREGEN.n6 XFE_O.NREGEN.n2 5.38537
R4828 XFE_O.NREGEN.n5 XFE_O.NREGEN.n4 5.38537
R4829 XFE_O.NREGEN.n28 XFE_O.NREGEN.n24 5.38537
R4830 XFE_O.NREGEN.n27 XFE_O.NREGEN.n26 5.38537
R4831 XFE_O.NREGEN.n12 XFE_O.NREGEN.n11 5.38537
R4832 XFE_O.NREGEN.n14 XFE_O.NREGEN.n13 5.38537
R4833 XFE_O.NREGEN.n16 XFE_O.NREGEN.n15 5.38537
R4834 XFE_O.NREGEN.n30 XFE_O.NREGEN.n29 4.5005
R4835 XFE_O.NREGEN.n21 XFE_O.NREGEN.n18 2.46572
R4836 XFE_O.NREGEN.n30 XFE_O.NREGEN.n21 1.91789
R4837 XFE_O.NREGEN.n8 XFE_O.NREGEN.t31 0.20525
R4838 XFE_O.NREGEN.n8 XFE_O.NREGEN.t33 0.20525
R4839 XFE_O.NREGEN.n19 XFE_O.NREGEN.t5 0.20525
R4840 XFE_O.NREGEN.n19 XFE_O.NREGEN.t11 0.20525
R4841 XFE_O.NREGEN.n1 XFE_O.NREGEN.t15 0.20525
R4842 XFE_O.NREGEN.n1 XFE_O.NREGEN.t4 0.20525
R4843 XFE_O.NREGEN.n2 XFE_O.NREGEN.t14 0.20525
R4844 XFE_O.NREGEN.n2 XFE_O.NREGEN.t7 0.20525
R4845 XFE_O.NREGEN.n4 XFE_O.NREGEN.t30 0.20525
R4846 XFE_O.NREGEN.n4 XFE_O.NREGEN.t1 0.20525
R4847 XFE_O.NREGEN.n3 XFE_O.NREGEN.t13 0.20525
R4848 XFE_O.NREGEN.n3 XFE_O.NREGEN.t12 0.20525
R4849 XFE_O.NREGEN.n23 XFE_O.NREGEN.t9 0.20525
R4850 XFE_O.NREGEN.n23 XFE_O.NREGEN.t8 0.20525
R4851 XFE_O.NREGEN.n24 XFE_O.NREGEN.t3 0.20525
R4852 XFE_O.NREGEN.n24 XFE_O.NREGEN.t29 0.20525
R4853 XFE_O.NREGEN.n26 XFE_O.NREGEN.t0 0.20525
R4854 XFE_O.NREGEN.n26 XFE_O.NREGEN.t2 0.20525
R4855 XFE_O.NREGEN.n25 XFE_O.NREGEN.t28 0.20525
R4856 XFE_O.NREGEN.n25 XFE_O.NREGEN.t6 0.20525
R4857 XFE_O.NREGEN.n11 XFE_O.NREGEN.t25 0.20525
R4858 XFE_O.NREGEN.n11 XFE_O.NREGEN.t26 0.20525
R4859 XFE_O.NREGEN.n13 XFE_O.NREGEN.t23 0.20525
R4860 XFE_O.NREGEN.n13 XFE_O.NREGEN.t24 0.20525
R4861 XFE_O.NREGEN.n15 XFE_O.NREGEN.t21 0.20525
R4862 XFE_O.NREGEN.n15 XFE_O.NREGEN.t22 0.20525
R4863 XFE_O.NREGEN.n14 XFE_O.NREGEN.n12 0.189974
R4864 XFE_O.NREGEN.n6 XFE_O.NREGEN.n5 0.189974
R4865 XFE_O.NREGEN.n28 XFE_O.NREGEN.n27 0.189974
R4866 XFE_O.NREGEN.n17 XFE_O.NREGEN.n16 0.0952368
R4867 XFE_O.NREGEN.n17 XFE_O.NREGEN.n14 0.0952368
R4868 XFE_O.NREGEN XFE_O.NREGEN.n30 0.0396304
R4869 XFE_E.NREGEN.n7 XFE_E.NREGEN.n0 18.0069
R4870 XFE_E.NREGEN.n15 XFE_E.NREGEN.n8 18.0069
R4871 XFE_E.NREGEN.n29 XFE_E.NREGEN.n28 10.6614
R4872 XFE_E.NREGEN.n18 XFE_E.NREGEN.n17 10.6614
R4873 XFE_E.NREGEN.n26 XFE_E.NREGEN.n25 9.32836
R4874 XFE_E.NREGEN.n7 XFE_E.NREGEN.n6 6.11407
R4875 XFE_E.NREGEN.n15 XFE_E.NREGEN.n14 6.11407
R4876 XFE_E.NREGEN.n18 XFE_E.NREGEN.n15 6.10485
R4877 XFE_E.NREGEN.n20 XFE_E.NREGEN.t25 5.7796
R4878 XFE_E.NREGEN.n22 XFE_E.NREGEN.t18 5.7796
R4879 XFE_E.NREGEN.n26 XFE_E.NREGEN.n18 5.75267
R4880 XFE_E.NREGEN.n0 XFE_E.NREGEN.t17 5.73764
R4881 XFE_E.NREGEN.n8 XFE_E.NREGEN.t15 5.73764
R4882 XFE_E.NREGEN.n28 XFE_E.NREGEN.t10 5.59012
R4883 XFE_E.NREGEN.n17 XFE_E.NREGEN.t29 5.59012
R4884 XFE_E.NREGEN.n28 XFE_E.NREGEN.n27 5.57485
R4885 XFE_E.NREGEN.n17 XFE_E.NREGEN.n16 5.57485
R4886 XFE_E.NREGEN.n3 XFE_E.NREGEN.n1 5.57485
R4887 XFE_E.NREGEN.n6 XFE_E.NREGEN.n5 5.57485
R4888 XFE_E.NREGEN.n11 XFE_E.NREGEN.n9 5.57485
R4889 XFE_E.NREGEN.n14 XFE_E.NREGEN.n13 5.57485
R4890 XFE_E.NREGEN.n0 XFE_E.NREGEN.t16 5.54817
R4891 XFE_E.NREGEN.n8 XFE_E.NREGEN.t14 5.54817
R4892 XFE_E.NREGEN.n3 XFE_E.NREGEN.n2 5.38537
R4893 XFE_E.NREGEN.n6 XFE_E.NREGEN.n4 5.38537
R4894 XFE_E.NREGEN.n11 XFE_E.NREGEN.n10 5.38537
R4895 XFE_E.NREGEN.n14 XFE_E.NREGEN.n12 5.38537
R4896 XFE_E.NREGEN.n20 XFE_E.NREGEN.n19 5.38537
R4897 XFE_E.NREGEN.n24 XFE_E.NREGEN.n23 5.38537
R4898 XFE_E.NREGEN.n22 XFE_E.NREGEN.n21 5.38537
R4899 XFE_E.NREGEN XFE_E.NREGEN.n7 4.53963
R4900 XFE_E.NREGEN.n29 XFE_E.NREGEN.n26 2.46572
R4901 XFE_E.NREGEN XFE_E.NREGEN.n29 1.87876
R4902 XFE_E.NREGEN.n27 XFE_E.NREGEN.t30 0.20525
R4903 XFE_E.NREGEN.n27 XFE_E.NREGEN.t3 0.20525
R4904 XFE_E.NREGEN.n16 XFE_E.NREGEN.t32 0.20525
R4905 XFE_E.NREGEN.n16 XFE_E.NREGEN.t31 0.20525
R4906 XFE_E.NREGEN.n1 XFE_E.NREGEN.t1 0.20525
R4907 XFE_E.NREGEN.n1 XFE_E.NREGEN.t2 0.20525
R4908 XFE_E.NREGEN.n2 XFE_E.NREGEN.t13 0.20525
R4909 XFE_E.NREGEN.n2 XFE_E.NREGEN.t7 0.20525
R4910 XFE_E.NREGEN.n4 XFE_E.NREGEN.t8 0.20525
R4911 XFE_E.NREGEN.n4 XFE_E.NREGEN.t33 0.20525
R4912 XFE_E.NREGEN.n5 XFE_E.NREGEN.t28 0.20525
R4913 XFE_E.NREGEN.n5 XFE_E.NREGEN.t11 0.20525
R4914 XFE_E.NREGEN.n9 XFE_E.NREGEN.t4 0.20525
R4915 XFE_E.NREGEN.n9 XFE_E.NREGEN.t9 0.20525
R4916 XFE_E.NREGEN.n10 XFE_E.NREGEN.t6 0.20525
R4917 XFE_E.NREGEN.n10 XFE_E.NREGEN.t0 0.20525
R4918 XFE_E.NREGEN.n12 XFE_E.NREGEN.t27 0.20525
R4919 XFE_E.NREGEN.n12 XFE_E.NREGEN.t26 0.20525
R4920 XFE_E.NREGEN.n13 XFE_E.NREGEN.t12 0.20525
R4921 XFE_E.NREGEN.n13 XFE_E.NREGEN.t5 0.20525
R4922 XFE_E.NREGEN.n19 XFE_E.NREGEN.t23 0.20525
R4923 XFE_E.NREGEN.n19 XFE_E.NREGEN.t24 0.20525
R4924 XFE_E.NREGEN.n23 XFE_E.NREGEN.t21 0.20525
R4925 XFE_E.NREGEN.n23 XFE_E.NREGEN.t22 0.20525
R4926 XFE_E.NREGEN.n21 XFE_E.NREGEN.t19 0.20525
R4927 XFE_E.NREGEN.n21 XFE_E.NREGEN.t20 0.20525
R4928 XFE_E.NREGEN.n24 XFE_E.NREGEN.n22 0.189974
R4929 XFE_E.NREGEN.n6 XFE_E.NREGEN.n3 0.189974
R4930 XFE_E.NREGEN.n14 XFE_E.NREGEN.n11 0.189974
R4931 XFE_E.NREGEN.n25 XFE_E.NREGEN.n24 0.0952368
R4932 XFE_E.NREGEN.n25 XFE_E.NREGEN.n20 0.0952368
R4933 XFE_O.XN.n70 XFE_O.XN.t57 127.788
R4934 XFE_O.XN.t50 XFE_O.XN.n60 127.788
R4935 XFE_O.XN.n67 XFE_O.XN.t53 127.668
R4936 XFE_O.XN.n70 XFE_O.XN.t56 127.668
R4937 XFE_O.XN.t55 XFE_O.XN.n71 127.668
R4938 XFE_O.XN.t54 XFE_O.XN.n68 127.668
R4939 XFE_O.XN.t51 XFE_O.XN.n60 127.668
R4940 XFE_O.XN.n66 XFE_O.XN.t52 127.668
R4941 XFE_O.XN.n22 XFE_O.XN.t41 113.632
R4942 XFE_O.XN.n5 XFE_O.XN.t49 113.632
R4943 XFE_O.XN.n76 XFE_O.XN.t37 113.632
R4944 XFE_O.XN.t57 XFE_O.XN.n57 113.632
R4945 XFE_O.XN.n63 XFE_O.XN.t50 113.632
R4946 XFE_O.XN.n23 XFE_O.XN.t40 109.174
R4947 XFE_O.XN.n24 XFE_O.XN.t39 109.174
R4948 XFE_O.XN.n25 XFE_O.XN.t38 109.174
R4949 XFE_O.XN.n0 XFE_O.XN.t42 109.174
R4950 XFE_O.XN.n11 XFE_O.XN.t43 109.174
R4951 XFE_O.XN.n10 XFE_O.XN.t44 109.174
R4952 XFE_O.XN.n6 XFE_O.XN.t48 109.174
R4953 XFE_O.XN.n7 XFE_O.XN.t47 109.174
R4954 XFE_O.XN.n8 XFE_O.XN.t46 109.174
R4955 XFE_O.XN.n9 XFE_O.XN.t45 109.174
R4956 XFE_O.XN.n77 XFE_O.XN.t36 109.174
R4957 XFE_O.XN.n78 XFE_O.XN.t35 109.174
R4958 XFE_O.XN.t53 XFE_O.XN.n59 109.174
R4959 XFE_O.XN.t56 XFE_O.XN.n58 109.174
R4960 XFE_O.XN.n72 XFE_O.XN.t55 109.174
R4961 XFE_O.XN.n69 XFE_O.XN.t54 109.174
R4962 XFE_O.XN.n64 XFE_O.XN.t51 109.174
R4963 XFE_O.XN.t52 XFE_O.XN.n65 109.174
R4964 XFE_O.XN.n46 XFE_O.XN.n45 21.0284
R4965 XFE_O.XN.n54 XFE_O.XN.n53 18.9712
R4966 XFE_O.XN.n13 XFE_O.XN.n0 18.5723
R4967 XFE_O.XN.n24 XFE_O.XN.n21 18.4942
R4968 XFE_O.XN.n26 XFE_O.XN.n25 18.4942
R4969 XFE_O.XN.n12 XFE_O.XN.n11 18.4942
R4970 XFE_O.XN.n10 XFE_O.XN.n1 18.4942
R4971 XFE_O.XN.n7 XFE_O.XN.n4 18.4942
R4972 XFE_O.XN.n8 XFE_O.XN.n3 18.4942
R4973 XFE_O.XN.n9 XFE_O.XN.n2 18.4942
R4974 XFE_O.XN.n79 XFE_O.XN.n78 18.4942
R4975 XFE_O.XN.n61 XFE_O.XN.n59 18.4942
R4976 XFE_O.XN.n73 XFE_O.XN.n72 18.4942
R4977 XFE_O.XN.n69 XFE_O.XN.n56 18.4942
R4978 XFE_O.XN.n65 XFE_O.XN.n62 18.4942
R4979 XFE_O.XN.n80 XFE_O.XN.n79 16.6599
R4980 XFE_O.XN.n38 XFE_O.XN.n35 12.6712
R4981 XFE_O.XN.n24 XFE_O.XN.n23 11.6805
R4982 XFE_O.XN.n25 XFE_O.XN.n24 11.6805
R4983 XFE_O.XN.n11 XFE_O.XN.n0 11.6805
R4984 XFE_O.XN.n11 XFE_O.XN.n10 11.6805
R4985 XFE_O.XN.n7 XFE_O.XN.n6 11.6805
R4986 XFE_O.XN.n8 XFE_O.XN.n7 11.6805
R4987 XFE_O.XN.n9 XFE_O.XN.n8 11.6805
R4988 XFE_O.XN.n10 XFE_O.XN.n9 11.6805
R4989 XFE_O.XN.n78 XFE_O.XN.n77 11.6805
R4990 XFE_O.XN.n72 XFE_O.XN.n69 11.6805
R4991 XFE_O.XN.n72 XFE_O.XN.n58 11.6805
R4992 XFE_O.XN.n69 XFE_O.XN.n59 11.6805
R4993 XFE_O.XN.n65 XFE_O.XN.n64 11.6805
R4994 XFE_O.XN.n65 XFE_O.XN.n59 11.6805
R4995 XFE_O.XN.n75 XFE_O.XN.n55 10.8396
R4996 XFE_O.XN.n28 XFE_O.XN.n13 10.7748
R4997 XFE_O.XN.n38 XFE_O.XN.n37 9.44001
R4998 XFE_O.XN.n27 XFE_O.XN.n26 9.1385
R4999 XFE_O.XN.n75 XFE_O.XN.n74 9.0005
R5000 XFE_O.XN.n22 XFE_O.XN.n21 7.17687
R5001 XFE_O.XN.n5 XFE_O.XN.n4 7.17687
R5002 XFE_O.XN.n79 XFE_O.XN.n76 7.17687
R5003 XFE_O.XN.n73 XFE_O.XN.n57 7.17687
R5004 XFE_O.XN.n63 XFE_O.XN.n62 7.17687
R5005 XFE_O.XN.n39 XFE_O.XN.n28 6.41789
R5006 XFE_O.XN.n27 XFE_O.XN.n20 6.40336
R5007 XFE_O.XN.n15 XFE_O.XN.t1 5.7796
R5008 XFE_O.XN.n19 XFE_O.XN.t4 5.7796
R5009 XFE_O.XN.n41 XFE_O.XN.t14 5.73764
R5010 XFE_O.XN.n30 XFE_O.XN.t31 5.73764
R5011 XFE_O.XN.n32 XFE_O.XN.t28 5.73764
R5012 XFE_O.XN.n45 XFE_O.XN.t7 5.73764
R5013 XFE_O.XN.n80 XFE_O.XN.n75 5.63193
R5014 XFE_O.XN.n37 XFE_O.XN.t32 5.59012
R5015 XFE_O.XN.n37 XFE_O.XN.n36 5.57485
R5016 XFE_O.XN.n50 XFE_O.XN.n48 5.51014
R5017 XFE_O.XN.n53 XFE_O.XN.n47 5.4154
R5018 XFE_O.XN.n15 XFE_O.XN.n14 5.38537
R5019 XFE_O.XN.n17 XFE_O.XN.n16 5.38537
R5020 XFE_O.XN.n19 XFE_O.XN.n18 5.38537
R5021 XFE_O.XN.n41 XFE_O.XN.n40 5.32067
R5022 XFE_O.XN.n43 XFE_O.XN.n42 5.32067
R5023 XFE_O.XN.n30 XFE_O.XN.n29 5.32067
R5024 XFE_O.XN.n34 XFE_O.XN.n33 5.32067
R5025 XFE_O.XN.n32 XFE_O.XN.n31 5.32067
R5026 XFE_O.XN.n52 XFE_O.XN.n51 5.32067
R5027 XFE_O.XN.n50 XFE_O.XN.n49 5.32067
R5028 XFE_O.XN.n45 XFE_O.XN.n44 5.32067
R5029 XFE_O.XN.n81 XFE_O.XN.n80 4.5005
R5030 XFE_O.XN.n39 XFE_O.XN.n38 4.5005
R5031 XFE_O.XN.n23 XFE_O.XN.n22 4.42851
R5032 XFE_O.XN.n6 XFE_O.XN.n5 4.42851
R5033 XFE_O.XN.n77 XFE_O.XN.n76 4.42851
R5034 XFE_O.XN.n58 XFE_O.XN.n57 4.42851
R5035 XFE_O.XN.n64 XFE_O.XN.n63 4.42851
R5036 XFE_O.XN.n81 XFE_O.XN.n54 3.95267
R5037 XFE_O.XN.n28 XFE_O.XN.n27 2.93193
R5038 XFE_O.XN.n46 XFE_O.XN.n39 1.76137
R5039 XFE_O.XN.n54 XFE_O.XN.n46 1.72224
R5040 XFE_O.XN.n40 XFE_O.XN.t12 0.228
R5041 XFE_O.XN.n40 XFE_O.XN.t13 0.228
R5042 XFE_O.XN.n42 XFE_O.XN.t10 0.228
R5043 XFE_O.XN.n42 XFE_O.XN.t11 0.228
R5044 XFE_O.XN.n29 XFE_O.XN.t27 0.228
R5045 XFE_O.XN.n29 XFE_O.XN.t26 0.228
R5046 XFE_O.XN.n33 XFE_O.XN.t30 0.228
R5047 XFE_O.XN.n33 XFE_O.XN.t29 0.228
R5048 XFE_O.XN.n31 XFE_O.XN.t25 0.228
R5049 XFE_O.XN.n31 XFE_O.XN.t24 0.228
R5050 XFE_O.XN.n47 XFE_O.XN.t21 0.228
R5051 XFE_O.XN.n47 XFE_O.XN.t22 0.228
R5052 XFE_O.XN.n51 XFE_O.XN.t19 0.228
R5053 XFE_O.XN.n51 XFE_O.XN.t20 0.228
R5054 XFE_O.XN.n49 XFE_O.XN.t17 0.228
R5055 XFE_O.XN.n49 XFE_O.XN.t18 0.228
R5056 XFE_O.XN.n48 XFE_O.XN.t15 0.228
R5057 XFE_O.XN.n48 XFE_O.XN.t16 0.228
R5058 XFE_O.XN.n44 XFE_O.XN.t8 0.228
R5059 XFE_O.XN.n44 XFE_O.XN.t9 0.228
R5060 XFE_O.XN.n14 XFE_O.XN.t2 0.20525
R5061 XFE_O.XN.n14 XFE_O.XN.t6 0.20525
R5062 XFE_O.XN.n16 XFE_O.XN.t0 0.20525
R5063 XFE_O.XN.n16 XFE_O.XN.t5 0.20525
R5064 XFE_O.XN.n18 XFE_O.XN.t3 0.20525
R5065 XFE_O.XN.n18 XFE_O.XN.t23 0.20525
R5066 XFE_O.XN.n36 XFE_O.XN.t34 0.20525
R5067 XFE_O.XN.n36 XFE_O.XN.t33 0.20525
R5068 XFE_O.XN.n45 XFE_O.XN.n43 0.189974
R5069 XFE_O.XN.n43 XFE_O.XN.n41 0.189974
R5070 XFE_O.XN.n17 XFE_O.XN.n15 0.189974
R5071 XFE_O.XN.n34 XFE_O.XN.n32 0.189974
R5072 XFE_O.XN.n52 XFE_O.XN.n50 0.189974
R5073 XFE_O.XN.n35 XFE_O.XN.n34 0.166289
R5074 XFE_O.XN.n26 XFE_O.XN.n21 0.1205
R5075 XFE_O.XN.n4 XFE_O.XN.n3 0.1205
R5076 XFE_O.XN.n3 XFE_O.XN.n2 0.1205
R5077 XFE_O.XN.n2 XFE_O.XN.n1 0.1205
R5078 XFE_O.XN.n62 XFE_O.XN.n61 0.1205
R5079 XFE_O.XN.n67 XFE_O.XN.n66 0.1205
R5080 XFE_O.XN.n66 XFE_O.XN.n60 0.1205
R5081 XFE_O.XN.n71 XFE_O.XN.n70 0.1205
R5082 XFE_O.XN.n12 XFE_O.XN.n1 0.114816
R5083 XFE_O.XN.n61 XFE_O.XN.n56 0.114816
R5084 XFE_O.XN.n68 XFE_O.XN.n67 0.114816
R5085 XFE_O.XN.n20 XFE_O.XN.n19 0.0952368
R5086 XFE_O.XN.n20 XFE_O.XN.n17 0.0952368
R5087 XFE_O.XN.n53 XFE_O.XN.n52 0.0952368
R5088 XFE_O.XN.n71 XFE_O.XN.n55 0.0785
R5089 XFE_O.XN.n74 XFE_O.XN.n73 0.0785
R5090 XFE_O.XN XFE_O.XN.n81 0.0396304
R5091 XFE_O.XN.n13 XFE_O.XN.n12 0.0241842
R5092 XFE_O.XN.n35 XFE_O.XN.n30 0.0241842
R5093 XFE_O.XN.n74 XFE_O.XN.n56 0.0241842
R5094 XFE_O.XN.n68 XFE_O.XN.n55 0.0241842
R5095 XFE_O.XP.n8 XFE_O.XP.t57 127.788
R5096 XFE_O.XP.t50 XFE_O.XP.n0 127.668
R5097 XFE_O.XP.t51 XFE_O.XP.n17 127.668
R5098 XFE_O.XP.n16 XFE_O.XP.t52 127.668
R5099 XFE_O.XP.n15 XFE_O.XP.t53 127.668
R5100 XFE_O.XP.t54 XFE_O.XP.n3 127.668
R5101 XFE_O.XP.t55 XFE_O.XP.n9 127.668
R5102 XFE_O.XP.n8 XFE_O.XP.t56 127.668
R5103 XFE_O.XP.n22 XFE_O.XP.t37 113.632
R5104 XFE_O.XP.t57 XFE_O.XP.n6 113.632
R5105 XFE_O.XP.n74 XFE_O.XP.t38 113.632
R5106 XFE_O.XP.n55 XFE_O.XP.t42 113.632
R5107 XFE_O.XP.n23 XFE_O.XP.t36 109.174
R5108 XFE_O.XP.n24 XFE_O.XP.t35 109.174
R5109 XFE_O.XP.n19 XFE_O.XP.t50 109.174
R5110 XFE_O.XP.n18 XFE_O.XP.t51 109.174
R5111 XFE_O.XP.t52 XFE_O.XP.n2 109.174
R5112 XFE_O.XP.t53 XFE_O.XP.n14 109.174
R5113 XFE_O.XP.n4 XFE_O.XP.t54 109.174
R5114 XFE_O.XP.n10 XFE_O.XP.t55 109.174
R5115 XFE_O.XP.t56 XFE_O.XP.n7 109.174
R5116 XFE_O.XP.n77 XFE_O.XP.t41 109.174
R5117 XFE_O.XP.n76 XFE_O.XP.t40 109.174
R5118 XFE_O.XP.n75 XFE_O.XP.t39 109.174
R5119 XFE_O.XP.n64 XFE_O.XP.t49 109.174
R5120 XFE_O.XP.n63 XFE_O.XP.t48 109.174
R5121 XFE_O.XP.n62 XFE_O.XP.t47 109.174
R5122 XFE_O.XP.n53 XFE_O.XP.t46 109.174
R5123 XFE_O.XP.n58 XFE_O.XP.t45 109.174
R5124 XFE_O.XP.n57 XFE_O.XP.t44 109.174
R5125 XFE_O.XP.n56 XFE_O.XP.t43 109.174
R5126 XFE_O.XP.n40 XFE_O.XP.n39 21.4784
R5127 XFE_O.XP.n33 XFE_O.XP.n32 21.4784
R5128 XFE_O.XP.n25 XFE_O.XP.n24 18.4942
R5129 XFE_O.XP.n20 XFE_O.XP.n19 18.4942
R5130 XFE_O.XP.n18 XFE_O.XP.n1 18.4942
R5131 XFE_O.XP.n5 XFE_O.XP.n2 18.4942
R5132 XFE_O.XP.n14 XFE_O.XP.n13 18.4942
R5133 XFE_O.XP.n12 XFE_O.XP.n4 18.4942
R5134 XFE_O.XP.n11 XFE_O.XP.n10 18.4942
R5135 XFE_O.XP.n78 XFE_O.XP.n77 18.4942
R5136 XFE_O.XP.n76 XFE_O.XP.n73 18.4942
R5137 XFE_O.XP.n65 XFE_O.XP.n64 18.4942
R5138 XFE_O.XP.n63 XFE_O.XP.n52 18.4942
R5139 XFE_O.XP.n62 XFE_O.XP.n61 18.4942
R5140 XFE_O.XP.n60 XFE_O.XP.n53 18.4942
R5141 XFE_O.XP.n59 XFE_O.XP.n58 18.4942
R5142 XFE_O.XP.n57 XFE_O.XP.n54 18.4942
R5143 XFE_O.XP.n26 XFE_O.XP.n25 16.2099
R5144 XFE_O.XP.n50 XFE_O.XP.n47 13.287
R5145 XFE_O.XP.n24 XFE_O.XP.n23 11.6805
R5146 XFE_O.XP.n19 XFE_O.XP.n18 11.6805
R5147 XFE_O.XP.n18 XFE_O.XP.n2 11.6805
R5148 XFE_O.XP.n14 XFE_O.XP.n2 11.6805
R5149 XFE_O.XP.n14 XFE_O.XP.n4 11.6805
R5150 XFE_O.XP.n10 XFE_O.XP.n4 11.6805
R5151 XFE_O.XP.n10 XFE_O.XP.n7 11.6805
R5152 XFE_O.XP.n77 XFE_O.XP.n76 11.6805
R5153 XFE_O.XP.n76 XFE_O.XP.n75 11.6805
R5154 XFE_O.XP.n64 XFE_O.XP.n63 11.6805
R5155 XFE_O.XP.n63 XFE_O.XP.n62 11.6805
R5156 XFE_O.XP.n62 XFE_O.XP.n53 11.6805
R5157 XFE_O.XP.n58 XFE_O.XP.n53 11.6805
R5158 XFE_O.XP.n58 XFE_O.XP.n57 11.6805
R5159 XFE_O.XP.n57 XFE_O.XP.n56 11.6805
R5160 XFE_O.XP.n80 XFE_O.XP.n65 11.3628
R5161 XFE_O.XP.n21 XFE_O.XP.n0 11.2176
R5162 XFE_O.XP.n33 XFE_O.XP.n26 9.3918
R5163 XFE_O.XP.n21 XFE_O.XP.n20 9.3785
R5164 XFE_O.XP.n79 XFE_O.XP.n78 9.3785
R5165 XFE_O.XP.n50 XFE_O.XP.n49 8.99001
R5166 XFE_O.XP.n25 XFE_O.XP.n22 7.17687
R5167 XFE_O.XP.n11 XFE_O.XP.n6 7.17687
R5168 XFE_O.XP.n74 XFE_O.XP.n73 7.17687
R5169 XFE_O.XP.n55 XFE_O.XP.n54 7.17687
R5170 XFE_O.XP.n79 XFE_O.XP.n72 6.40336
R5171 XFE_O.XP.n26 XFE_O.XP.n21 6.08193
R5172 XFE_O.XP.n67 XFE_O.XP.t4 5.7796
R5173 XFE_O.XP.n71 XFE_O.XP.t22 5.7796
R5174 XFE_O.XP.n39 XFE_O.XP.t13 5.73764
R5175 XFE_O.XP.n42 XFE_O.XP.t25 5.73764
R5176 XFE_O.XP.n28 XFE_O.XP.t21 5.73764
R5177 XFE_O.XP.n32 XFE_O.XP.t14 5.73764
R5178 XFE_O.XP.n35 XFE_O.XP.t6 5.73764
R5179 XFE_O.XP.n49 XFE_O.XP.t31 5.59012
R5180 XFE_O.XP.n49 XFE_O.XP.n48 5.57485
R5181 XFE_O.XP.n47 XFE_O.XP.t26 5.54817
R5182 XFE_O.XP.n67 XFE_O.XP.n66 5.38537
R5183 XFE_O.XP.n69 XFE_O.XP.n68 5.38537
R5184 XFE_O.XP.n71 XFE_O.XP.n70 5.38537
R5185 XFE_O.XP.n42 XFE_O.XP.n41 5.32067
R5186 XFE_O.XP.n44 XFE_O.XP.n43 5.32067
R5187 XFE_O.XP.n46 XFE_O.XP.n45 5.32067
R5188 XFE_O.XP.n28 XFE_O.XP.n27 5.32067
R5189 XFE_O.XP.n30 XFE_O.XP.n29 5.32067
R5190 XFE_O.XP.n32 XFE_O.XP.n31 5.32067
R5191 XFE_O.XP.n39 XFE_O.XP.n38 5.32067
R5192 XFE_O.XP.n37 XFE_O.XP.n36 5.32067
R5193 XFE_O.XP.n35 XFE_O.XP.n34 5.32067
R5194 XFE_O.XP.n51 XFE_O.XP.n50 4.5005
R5195 XFE_O.XP.n81 XFE_O.XP.n80 4.5005
R5196 XFE_O.XP.n23 XFE_O.XP.n22 4.42851
R5197 XFE_O.XP.n7 XFE_O.XP.n6 4.42851
R5198 XFE_O.XP.n75 XFE_O.XP.n74 4.42851
R5199 XFE_O.XP.n56 XFE_O.XP.n55 4.42851
R5200 XFE_O.XP.n80 XFE_O.XP.n79 2.48193
R5201 XFE_O.XP.n51 XFE_O.XP.n40 2.38746
R5202 XFE_O.XP.n40 XFE_O.XP.n33 1.72224
R5203 XFE_O.XP.n81 XFE_O.XP.n51 1.60485
R5204 XFE_O.XP.n41 XFE_O.XP.t29 0.228
R5205 XFE_O.XP.n41 XFE_O.XP.t30 0.228
R5206 XFE_O.XP.n43 XFE_O.XP.t23 0.228
R5207 XFE_O.XP.n43 XFE_O.XP.t24 0.228
R5208 XFE_O.XP.n45 XFE_O.XP.t27 0.228
R5209 XFE_O.XP.n45 XFE_O.XP.t28 0.228
R5210 XFE_O.XP.n27 XFE_O.XP.t19 0.228
R5211 XFE_O.XP.n27 XFE_O.XP.t20 0.228
R5212 XFE_O.XP.n29 XFE_O.XP.t17 0.228
R5213 XFE_O.XP.n29 XFE_O.XP.t18 0.228
R5214 XFE_O.XP.n31 XFE_O.XP.t15 0.228
R5215 XFE_O.XP.n31 XFE_O.XP.t16 0.228
R5216 XFE_O.XP.n38 XFE_O.XP.t11 0.228
R5217 XFE_O.XP.n38 XFE_O.XP.t12 0.228
R5218 XFE_O.XP.n36 XFE_O.XP.t9 0.228
R5219 XFE_O.XP.n36 XFE_O.XP.t10 0.228
R5220 XFE_O.XP.n34 XFE_O.XP.t7 0.228
R5221 XFE_O.XP.n34 XFE_O.XP.t8 0.228
R5222 XFE_O.XP.n66 XFE_O.XP.t34 0.20525
R5223 XFE_O.XP.n66 XFE_O.XP.t5 0.20525
R5224 XFE_O.XP.n68 XFE_O.XP.t1 0.20525
R5225 XFE_O.XP.n68 XFE_O.XP.t2 0.20525
R5226 XFE_O.XP.n70 XFE_O.XP.t3 0.20525
R5227 XFE_O.XP.n70 XFE_O.XP.t0 0.20525
R5228 XFE_O.XP.n48 XFE_O.XP.t32 0.20525
R5229 XFE_O.XP.n48 XFE_O.XP.t33 0.20525
R5230 XFE_O.XP.n37 XFE_O.XP.n35 0.189974
R5231 XFE_O.XP.n39 XFE_O.XP.n37 0.189974
R5232 XFE_O.XP.n69 XFE_O.XP.n67 0.189974
R5233 XFE_O.XP.n47 XFE_O.XP.n46 0.189974
R5234 XFE_O.XP.n46 XFE_O.XP.n44 0.189974
R5235 XFE_O.XP.n44 XFE_O.XP.n42 0.189974
R5236 XFE_O.XP.n32 XFE_O.XP.n30 0.189974
R5237 XFE_O.XP.n30 XFE_O.XP.n28 0.189974
R5238 XFE_O.XP.n12 XFE_O.XP.n11 0.1205
R5239 XFE_O.XP.n13 XFE_O.XP.n12 0.1205
R5240 XFE_O.XP.n13 XFE_O.XP.n5 0.1205
R5241 XFE_O.XP.n5 XFE_O.XP.n1 0.1205
R5242 XFE_O.XP.n20 XFE_O.XP.n1 0.1205
R5243 XFE_O.XP.n9 XFE_O.XP.n8 0.1205
R5244 XFE_O.XP.n9 XFE_O.XP.n3 0.1205
R5245 XFE_O.XP.n15 XFE_O.XP.n3 0.1205
R5246 XFE_O.XP.n16 XFE_O.XP.n15 0.1205
R5247 XFE_O.XP.n17 XFE_O.XP.n16 0.1205
R5248 XFE_O.XP.n17 XFE_O.XP.n0 0.1205
R5249 XFE_O.XP.n78 XFE_O.XP.n73 0.1205
R5250 XFE_O.XP.n65 XFE_O.XP.n52 0.1205
R5251 XFE_O.XP.n61 XFE_O.XP.n52 0.1205
R5252 XFE_O.XP.n61 XFE_O.XP.n60 0.1205
R5253 XFE_O.XP.n60 XFE_O.XP.n59 0.1205
R5254 XFE_O.XP.n59 XFE_O.XP.n54 0.1205
R5255 XFE_O.XP.n72 XFE_O.XP.n71 0.0952368
R5256 XFE_O.XP.n72 XFE_O.XP.n69 0.0952368
R5257 XFE_O.XP XFE_O.XP.n81 0.0396304
R5258 XFE_E.XP.t50 XFE_E.XP.n40 127.788
R5259 XFE_E.XP.t57 XFE_E.XP.n29 127.668
R5260 XFE_E.XP.n40 XFE_E.XP.t51 127.668
R5261 XFE_E.XP.n39 XFE_E.XP.t52 127.668
R5262 XFE_E.XP.n38 XFE_E.XP.t53 127.668
R5263 XFE_E.XP.n37 XFE_E.XP.t54 127.668
R5264 XFE_E.XP.n36 XFE_E.XP.t55 127.668
R5265 XFE_E.XP.n35 XFE_E.XP.t56 127.668
R5266 XFE_E.XP.n22 XFE_E.XP.t41 113.632
R5267 XFE_E.XP.n5 XFE_E.XP.t49 113.632
R5268 XFE_E.XP.n51 XFE_E.XP.t35 113.632
R5269 XFE_E.XP.n41 XFE_E.XP.t50 113.632
R5270 XFE_E.XP.n23 XFE_E.XP.t40 109.174
R5271 XFE_E.XP.n24 XFE_E.XP.t39 109.174
R5272 XFE_E.XP.n25 XFE_E.XP.t38 109.174
R5273 XFE_E.XP.n6 XFE_E.XP.t48 109.174
R5274 XFE_E.XP.n7 XFE_E.XP.t47 109.174
R5275 XFE_E.XP.n8 XFE_E.XP.t46 109.174
R5276 XFE_E.XP.n9 XFE_E.XP.t45 109.174
R5277 XFE_E.XP.n10 XFE_E.XP.t44 109.174
R5278 XFE_E.XP.n11 XFE_E.XP.t43 109.174
R5279 XFE_E.XP.n12 XFE_E.XP.t42 109.174
R5280 XFE_E.XP.n53 XFE_E.XP.t37 109.174
R5281 XFE_E.XP.n52 XFE_E.XP.t36 109.174
R5282 XFE_E.XP.n48 XFE_E.XP.t57 109.174
R5283 XFE_E.XP.n42 XFE_E.XP.t51 109.174
R5284 XFE_E.XP.n43 XFE_E.XP.t52 109.174
R5285 XFE_E.XP.n44 XFE_E.XP.t53 109.174
R5286 XFE_E.XP.n45 XFE_E.XP.t54 109.174
R5287 XFE_E.XP.n46 XFE_E.XP.t55 109.174
R5288 XFE_E.XP.n47 XFE_E.XP.t56 109.174
R5289 XFE_E.XP.n69 XFE_E.XP.n68 21.4784
R5290 XFE_E.XP.n62 XFE_E.XP.n61 21.4784
R5291 XFE_E.XP.n24 XFE_E.XP.n21 18.4942
R5292 XFE_E.XP.n26 XFE_E.XP.n25 18.4942
R5293 XFE_E.XP.n7 XFE_E.XP.n4 18.4942
R5294 XFE_E.XP.n8 XFE_E.XP.n3 18.4942
R5295 XFE_E.XP.n9 XFE_E.XP.n2 18.4942
R5296 XFE_E.XP.n10 XFE_E.XP.n1 18.4942
R5297 XFE_E.XP.n11 XFE_E.XP.n0 18.4942
R5298 XFE_E.XP.n13 XFE_E.XP.n12 18.4942
R5299 XFE_E.XP.n54 XFE_E.XP.n53 18.4942
R5300 XFE_E.XP.n49 XFE_E.XP.n48 18.4942
R5301 XFE_E.XP.n43 XFE_E.XP.n34 18.4942
R5302 XFE_E.XP.n44 XFE_E.XP.n33 18.4942
R5303 XFE_E.XP.n45 XFE_E.XP.n32 18.4942
R5304 XFE_E.XP.n46 XFE_E.XP.n31 18.4942
R5305 XFE_E.XP.n47 XFE_E.XP.n30 18.4942
R5306 XFE_E.XP.n55 XFE_E.XP.n54 16.2099
R5307 XFE_E.XP.n79 XFE_E.XP.n76 13.287
R5308 XFE_E.XP.n24 XFE_E.XP.n23 11.6805
R5309 XFE_E.XP.n25 XFE_E.XP.n24 11.6805
R5310 XFE_E.XP.n7 XFE_E.XP.n6 11.6805
R5311 XFE_E.XP.n8 XFE_E.XP.n7 11.6805
R5312 XFE_E.XP.n9 XFE_E.XP.n8 11.6805
R5313 XFE_E.XP.n10 XFE_E.XP.n9 11.6805
R5314 XFE_E.XP.n11 XFE_E.XP.n10 11.6805
R5315 XFE_E.XP.n12 XFE_E.XP.n11 11.6805
R5316 XFE_E.XP.n53 XFE_E.XP.n52 11.6805
R5317 XFE_E.XP.n43 XFE_E.XP.n42 11.6805
R5318 XFE_E.XP.n44 XFE_E.XP.n43 11.6805
R5319 XFE_E.XP.n45 XFE_E.XP.n44 11.6805
R5320 XFE_E.XP.n46 XFE_E.XP.n45 11.6805
R5321 XFE_E.XP.n47 XFE_E.XP.n46 11.6805
R5322 XFE_E.XP.n48 XFE_E.XP.n47 11.6805
R5323 XFE_E.XP.n28 XFE_E.XP.n13 11.3628
R5324 XFE_E.XP.n50 XFE_E.XP.n29 11.2176
R5325 XFE_E.XP.n62 XFE_E.XP.n55 9.3918
R5326 XFE_E.XP.n27 XFE_E.XP.n26 9.3785
R5327 XFE_E.XP.n50 XFE_E.XP.n49 9.3785
R5328 XFE_E.XP.n79 XFE_E.XP.n78 8.99001
R5329 XFE_E.XP.n22 XFE_E.XP.n21 7.17687
R5330 XFE_E.XP.n5 XFE_E.XP.n4 7.17687
R5331 XFE_E.XP.n54 XFE_E.XP.n51 7.17687
R5332 XFE_E.XP.n41 XFE_E.XP.n34 7.17687
R5333 XFE_E.XP.n27 XFE_E.XP.n20 6.40336
R5334 XFE_E.XP.n55 XFE_E.XP.n50 6.08193
R5335 XFE_E.XP.n15 XFE_E.XP.t1 5.7796
R5336 XFE_E.XP.n17 XFE_E.XP.t31 5.7796
R5337 XFE_E.XP.n64 XFE_E.XP.t25 5.73764
R5338 XFE_E.XP.n71 XFE_E.XP.t12 5.73764
R5339 XFE_E.XP.n61 XFE_E.XP.t15 5.73764
R5340 XFE_E.XP.n58 XFE_E.XP.t14 5.73764
R5341 XFE_E.XP.n68 XFE_E.XP.t18 5.73764
R5342 XFE_E.XP.n78 XFE_E.XP.t2 5.59012
R5343 XFE_E.XP.n78 XFE_E.XP.n77 5.57485
R5344 XFE_E.XP.n76 XFE_E.XP.t8 5.54817
R5345 XFE_E.XP.n15 XFE_E.XP.n14 5.38537
R5346 XFE_E.XP.n19 XFE_E.XP.n18 5.38537
R5347 XFE_E.XP.n17 XFE_E.XP.n16 5.38537
R5348 XFE_E.XP.n64 XFE_E.XP.n63 5.32067
R5349 XFE_E.XP.n66 XFE_E.XP.n65 5.32067
R5350 XFE_E.XP.n75 XFE_E.XP.n74 5.32067
R5351 XFE_E.XP.n73 XFE_E.XP.n72 5.32067
R5352 XFE_E.XP.n71 XFE_E.XP.n70 5.32067
R5353 XFE_E.XP.n61 XFE_E.XP.n56 5.32067
R5354 XFE_E.XP.n60 XFE_E.XP.n59 5.32067
R5355 XFE_E.XP.n58 XFE_E.XP.n57 5.32067
R5356 XFE_E.XP.n68 XFE_E.XP.n67 5.32067
R5357 XFE_E.XP XFE_E.XP.n28 4.53963
R5358 XFE_E.XP.n80 XFE_E.XP.n79 4.5005
R5359 XFE_E.XP.n23 XFE_E.XP.n22 4.42851
R5360 XFE_E.XP.n6 XFE_E.XP.n5 4.42851
R5361 XFE_E.XP.n52 XFE_E.XP.n51 4.42851
R5362 XFE_E.XP.n42 XFE_E.XP.n41 4.42851
R5363 XFE_E.XP.n28 XFE_E.XP.n27 2.48193
R5364 XFE_E.XP.n80 XFE_E.XP.n69 2.38746
R5365 XFE_E.XP.n69 XFE_E.XP.n62 1.72224
R5366 XFE_E.XP XFE_E.XP.n80 1.56572
R5367 XFE_E.XP.n63 XFE_E.XP.t23 0.228
R5368 XFE_E.XP.n63 XFE_E.XP.t24 0.228
R5369 XFE_E.XP.n65 XFE_E.XP.t21 0.228
R5370 XFE_E.XP.n65 XFE_E.XP.t22 0.228
R5371 XFE_E.XP.n74 XFE_E.XP.t6 0.228
R5372 XFE_E.XP.n74 XFE_E.XP.t11 0.228
R5373 XFE_E.XP.n72 XFE_E.XP.t30 0.228
R5374 XFE_E.XP.n72 XFE_E.XP.t9 0.228
R5375 XFE_E.XP.n70 XFE_E.XP.t32 0.228
R5376 XFE_E.XP.n70 XFE_E.XP.t5 0.228
R5377 XFE_E.XP.n56 XFE_E.XP.t26 0.228
R5378 XFE_E.XP.n56 XFE_E.XP.t27 0.228
R5379 XFE_E.XP.n59 XFE_E.XP.t28 0.228
R5380 XFE_E.XP.n59 XFE_E.XP.t29 0.228
R5381 XFE_E.XP.n57 XFE_E.XP.t16 0.228
R5382 XFE_E.XP.n57 XFE_E.XP.t17 0.228
R5383 XFE_E.XP.n67 XFE_E.XP.t19 0.228
R5384 XFE_E.XP.n67 XFE_E.XP.t20 0.228
R5385 XFE_E.XP.n14 XFE_E.XP.t3 0.20525
R5386 XFE_E.XP.n14 XFE_E.XP.t0 0.20525
R5387 XFE_E.XP.n18 XFE_E.XP.t34 0.20525
R5388 XFE_E.XP.n18 XFE_E.XP.t13 0.20525
R5389 XFE_E.XP.n16 XFE_E.XP.t10 0.20525
R5390 XFE_E.XP.n16 XFE_E.XP.t4 0.20525
R5391 XFE_E.XP.n77 XFE_E.XP.t7 0.20525
R5392 XFE_E.XP.n77 XFE_E.XP.t33 0.20525
R5393 XFE_E.XP.n68 XFE_E.XP.n66 0.189974
R5394 XFE_E.XP.n66 XFE_E.XP.n64 0.189974
R5395 XFE_E.XP.n19 XFE_E.XP.n17 0.189974
R5396 XFE_E.XP.n73 XFE_E.XP.n71 0.189974
R5397 XFE_E.XP.n75 XFE_E.XP.n73 0.189974
R5398 XFE_E.XP.n76 XFE_E.XP.n75 0.189974
R5399 XFE_E.XP.n60 XFE_E.XP.n58 0.189974
R5400 XFE_E.XP.n61 XFE_E.XP.n60 0.189974
R5401 XFE_E.XP.n26 XFE_E.XP.n21 0.1205
R5402 XFE_E.XP.n4 XFE_E.XP.n3 0.1205
R5403 XFE_E.XP.n3 XFE_E.XP.n2 0.1205
R5404 XFE_E.XP.n2 XFE_E.XP.n1 0.1205
R5405 XFE_E.XP.n1 XFE_E.XP.n0 0.1205
R5406 XFE_E.XP.n13 XFE_E.XP.n0 0.1205
R5407 XFE_E.XP.n49 XFE_E.XP.n30 0.1205
R5408 XFE_E.XP.n31 XFE_E.XP.n30 0.1205
R5409 XFE_E.XP.n32 XFE_E.XP.n31 0.1205
R5410 XFE_E.XP.n33 XFE_E.XP.n32 0.1205
R5411 XFE_E.XP.n34 XFE_E.XP.n33 0.1205
R5412 XFE_E.XP.n35 XFE_E.XP.n29 0.1205
R5413 XFE_E.XP.n36 XFE_E.XP.n35 0.1205
R5414 XFE_E.XP.n37 XFE_E.XP.n36 0.1205
R5415 XFE_E.XP.n38 XFE_E.XP.n37 0.1205
R5416 XFE_E.XP.n39 XFE_E.XP.n38 0.1205
R5417 XFE_E.XP.n40 XFE_E.XP.n39 0.1205
R5418 XFE_E.XP.n20 XFE_E.XP.n19 0.0952368
R5419 XFE_E.XP.n20 XFE_E.XP.n15 0.0952368
R5420 XFE_E.XN.t57 XFE_E.XN.n12 127.788
R5421 XFE_E.XN.n5 XFE_E.XN.t50 127.788
R5422 XFE_E.XN.t52 XFE_E.XN.n6 127.668
R5423 XFE_E.XN.n12 XFE_E.XN.t56 127.668
R5424 XFE_E.XN.n11 XFE_E.XN.t55 127.668
R5425 XFE_E.XN.n10 XFE_E.XN.t54 127.668
R5426 XFE_E.XN.n9 XFE_E.XN.t53 127.668
R5427 XFE_E.XN.n5 XFE_E.XN.t51 127.668
R5428 XFE_E.XN.n21 XFE_E.XN.t35 113.632
R5429 XFE_E.XN.n13 XFE_E.XN.t57 113.632
R5430 XFE_E.XN.t50 XFE_E.XN.n4 113.632
R5431 XFE_E.XN.n48 XFE_E.XN.t38 113.632
R5432 XFE_E.XN.n29 XFE_E.XN.t42 113.632
R5433 XFE_E.XN.n23 XFE_E.XN.t37 109.174
R5434 XFE_E.XN.n22 XFE_E.XN.t36 109.174
R5435 XFE_E.XN.n7 XFE_E.XN.t52 109.174
R5436 XFE_E.XN.t56 XFE_E.XN.n8 109.174
R5437 XFE_E.XN.n15 XFE_E.XN.t55 109.174
R5438 XFE_E.XN.n16 XFE_E.XN.t54 109.174
R5439 XFE_E.XN.n17 XFE_E.XN.t53 109.174
R5440 XFE_E.XN.t51 XFE_E.XN.n3 109.174
R5441 XFE_E.XN.n51 XFE_E.XN.t41 109.174
R5442 XFE_E.XN.n50 XFE_E.XN.t40 109.174
R5443 XFE_E.XN.n49 XFE_E.XN.t39 109.174
R5444 XFE_E.XN.n36 XFE_E.XN.t47 109.174
R5445 XFE_E.XN.n37 XFE_E.XN.t48 109.174
R5446 XFE_E.XN.n38 XFE_E.XN.t49 109.174
R5447 XFE_E.XN.n27 XFE_E.XN.t46 109.174
R5448 XFE_E.XN.n32 XFE_E.XN.t45 109.174
R5449 XFE_E.XN.n31 XFE_E.XN.t44 109.174
R5450 XFE_E.XN.n30 XFE_E.XN.t43 109.174
R5451 XFE_E.XN.n72 XFE_E.XN.n71 21.0284
R5452 XFE_E.XN.n80 XFE_E.XN.n79 18.9712
R5453 XFE_E.XN.n39 XFE_E.XN.n38 18.5723
R5454 XFE_E.XN.n24 XFE_E.XN.n23 18.4942
R5455 XFE_E.XN.n7 XFE_E.XN.n1 18.4942
R5456 XFE_E.XN.n15 XFE_E.XN.n14 18.4942
R5457 XFE_E.XN.n16 XFE_E.XN.n2 18.4942
R5458 XFE_E.XN.n18 XFE_E.XN.n17 18.4942
R5459 XFE_E.XN.n52 XFE_E.XN.n51 18.4942
R5460 XFE_E.XN.n50 XFE_E.XN.n47 18.4942
R5461 XFE_E.XN.n36 XFE_E.XN.n35 18.4942
R5462 XFE_E.XN.n37 XFE_E.XN.n26 18.4942
R5463 XFE_E.XN.n34 XFE_E.XN.n27 18.4942
R5464 XFE_E.XN.n33 XFE_E.XN.n32 18.4942
R5465 XFE_E.XN.n31 XFE_E.XN.n28 18.4942
R5466 XFE_E.XN.n25 XFE_E.XN.n24 16.6599
R5467 XFE_E.XN.n64 XFE_E.XN.n61 12.6712
R5468 XFE_E.XN.n23 XFE_E.XN.n22 11.6805
R5469 XFE_E.XN.n16 XFE_E.XN.n15 11.6805
R5470 XFE_E.XN.n15 XFE_E.XN.n8 11.6805
R5471 XFE_E.XN.n17 XFE_E.XN.n16 11.6805
R5472 XFE_E.XN.n17 XFE_E.XN.n7 11.6805
R5473 XFE_E.XN.n7 XFE_E.XN.n3 11.6805
R5474 XFE_E.XN.n51 XFE_E.XN.n50 11.6805
R5475 XFE_E.XN.n50 XFE_E.XN.n49 11.6805
R5476 XFE_E.XN.n36 XFE_E.XN.n27 11.6805
R5477 XFE_E.XN.n37 XFE_E.XN.n36 11.6805
R5478 XFE_E.XN.n38 XFE_E.XN.n37 11.6805
R5479 XFE_E.XN.n32 XFE_E.XN.n27 11.6805
R5480 XFE_E.XN.n32 XFE_E.XN.n31 11.6805
R5481 XFE_E.XN.n31 XFE_E.XN.n30 11.6805
R5482 XFE_E.XN.n20 XFE_E.XN.n0 10.8396
R5483 XFE_E.XN.n54 XFE_E.XN.n39 10.7748
R5484 XFE_E.XN.n64 XFE_E.XN.n63 9.44001
R5485 XFE_E.XN.n53 XFE_E.XN.n52 9.1385
R5486 XFE_E.XN.n20 XFE_E.XN.n19 9.0005
R5487 XFE_E.XN.n24 XFE_E.XN.n21 7.17687
R5488 XFE_E.XN.n14 XFE_E.XN.n13 7.17687
R5489 XFE_E.XN.n4 XFE_E.XN.n1 7.17687
R5490 XFE_E.XN.n48 XFE_E.XN.n47 7.17687
R5491 XFE_E.XN.n29 XFE_E.XN.n28 7.17687
R5492 XFE_E.XN.n65 XFE_E.XN.n54 6.41789
R5493 XFE_E.XN.n53 XFE_E.XN.n46 6.40336
R5494 XFE_E.XN.n41 XFE_E.XN.t4 5.7796
R5495 XFE_E.XN.n43 XFE_E.XN.t5 5.7796
R5496 XFE_E.XN.n71 XFE_E.XN.t13 5.73764
R5497 XFE_E.XN.n56 XFE_E.XN.t24 5.73764
R5498 XFE_E.XN.n60 XFE_E.XN.t29 5.73764
R5499 XFE_E.XN.n67 XFE_E.XN.t6 5.73764
R5500 XFE_E.XN.n25 XFE_E.XN.n20 5.63193
R5501 XFE_E.XN.n63 XFE_E.XN.t32 5.59012
R5502 XFE_E.XN.n63 XFE_E.XN.n62 5.57485
R5503 XFE_E.XN.n75 XFE_E.XN.n73 5.51014
R5504 XFE_E.XN.n79 XFE_E.XN.n78 5.4154
R5505 XFE_E.XN.n41 XFE_E.XN.n40 5.38537
R5506 XFE_E.XN.n45 XFE_E.XN.n44 5.38537
R5507 XFE_E.XN.n43 XFE_E.XN.n42 5.38537
R5508 XFE_E.XN.n75 XFE_E.XN.n74 5.32067
R5509 XFE_E.XN.n77 XFE_E.XN.n76 5.32067
R5510 XFE_E.XN.n56 XFE_E.XN.n55 5.32067
R5511 XFE_E.XN.n58 XFE_E.XN.n57 5.32067
R5512 XFE_E.XN.n60 XFE_E.XN.n59 5.32067
R5513 XFE_E.XN.n71 XFE_E.XN.n70 5.32067
R5514 XFE_E.XN.n69 XFE_E.XN.n68 5.32067
R5515 XFE_E.XN.n67 XFE_E.XN.n66 5.32067
R5516 XFE_E.XN XFE_E.XN.n25 4.53963
R5517 XFE_E.XN.n65 XFE_E.XN.n64 4.5005
R5518 XFE_E.XN.n22 XFE_E.XN.n21 4.42851
R5519 XFE_E.XN.n13 XFE_E.XN.n8 4.42851
R5520 XFE_E.XN.n4 XFE_E.XN.n3 4.42851
R5521 XFE_E.XN.n49 XFE_E.XN.n48 4.42851
R5522 XFE_E.XN.n30 XFE_E.XN.n29 4.42851
R5523 XFE_E.XN XFE_E.XN.n80 3.91354
R5524 XFE_E.XN.n54 XFE_E.XN.n53 2.93193
R5525 XFE_E.XN.n72 XFE_E.XN.n65 1.76137
R5526 XFE_E.XN.n80 XFE_E.XN.n72 1.72224
R5527 XFE_E.XN.n73 XFE_E.XN.t20 0.228
R5528 XFE_E.XN.n73 XFE_E.XN.t21 0.228
R5529 XFE_E.XN.n74 XFE_E.XN.t18 0.228
R5530 XFE_E.XN.n74 XFE_E.XN.t19 0.228
R5531 XFE_E.XN.n76 XFE_E.XN.t16 0.228
R5532 XFE_E.XN.n76 XFE_E.XN.t17 0.228
R5533 XFE_E.XN.n78 XFE_E.XN.t14 0.228
R5534 XFE_E.XN.n78 XFE_E.XN.t15 0.228
R5535 XFE_E.XN.n55 XFE_E.XN.t33 0.228
R5536 XFE_E.XN.n55 XFE_E.XN.t34 0.228
R5537 XFE_E.XN.n57 XFE_E.XN.t25 0.228
R5538 XFE_E.XN.n57 XFE_E.XN.t26 0.228
R5539 XFE_E.XN.n59 XFE_E.XN.t27 0.228
R5540 XFE_E.XN.n59 XFE_E.XN.t28 0.228
R5541 XFE_E.XN.n70 XFE_E.XN.t11 0.228
R5542 XFE_E.XN.n70 XFE_E.XN.t12 0.228
R5543 XFE_E.XN.n68 XFE_E.XN.t9 0.228
R5544 XFE_E.XN.n68 XFE_E.XN.t10 0.228
R5545 XFE_E.XN.n66 XFE_E.XN.t7 0.228
R5546 XFE_E.XN.n66 XFE_E.XN.t8 0.228
R5547 XFE_E.XN.n40 XFE_E.XN.t0 0.20525
R5548 XFE_E.XN.n40 XFE_E.XN.t1 0.20525
R5549 XFE_E.XN.n44 XFE_E.XN.t22 0.20525
R5550 XFE_E.XN.n44 XFE_E.XN.t3 0.20525
R5551 XFE_E.XN.n42 XFE_E.XN.t2 0.20525
R5552 XFE_E.XN.n42 XFE_E.XN.t23 0.20525
R5553 XFE_E.XN.n62 XFE_E.XN.t30 0.20525
R5554 XFE_E.XN.n62 XFE_E.XN.t31 0.20525
R5555 XFE_E.XN.n69 XFE_E.XN.n67 0.189974
R5556 XFE_E.XN.n71 XFE_E.XN.n69 0.189974
R5557 XFE_E.XN.n77 XFE_E.XN.n75 0.189974
R5558 XFE_E.XN.n45 XFE_E.XN.n43 0.189974
R5559 XFE_E.XN.n58 XFE_E.XN.n56 0.189974
R5560 XFE_E.XN.n61 XFE_E.XN.n58 0.166289
R5561 XFE_E.XN.n6 XFE_E.XN.n5 0.1205
R5562 XFE_E.XN.n12 XFE_E.XN.n11 0.1205
R5563 XFE_E.XN.n11 XFE_E.XN.n10 0.1205
R5564 XFE_E.XN.n14 XFE_E.XN.n2 0.1205
R5565 XFE_E.XN.n52 XFE_E.XN.n47 0.1205
R5566 XFE_E.XN.n35 XFE_E.XN.n34 0.1205
R5567 XFE_E.XN.n34 XFE_E.XN.n33 0.1205
R5568 XFE_E.XN.n33 XFE_E.XN.n28 0.1205
R5569 XFE_E.XN.n10 XFE_E.XN.n9 0.114816
R5570 XFE_E.XN.n18 XFE_E.XN.n2 0.114816
R5571 XFE_E.XN.n35 XFE_E.XN.n26 0.114816
R5572 XFE_E.XN.n79 XFE_E.XN.n77 0.0952368
R5573 XFE_E.XN.n46 XFE_E.XN.n45 0.0952368
R5574 XFE_E.XN.n46 XFE_E.XN.n41 0.0952368
R5575 XFE_E.XN.n19 XFE_E.XN.n1 0.0785
R5576 XFE_E.XN.n6 XFE_E.XN.n0 0.0785
R5577 XFE_E.XN.n19 XFE_E.XN.n18 0.0241842
R5578 XFE_E.XN.n9 XFE_E.XN.n0 0.0241842
R5579 XFE_E.XN.n39 XFE_E.XN.n26 0.0241842
R5580 XFE_E.XN.n61 XFE_E.XN.n60 0.0241842
R5581 XFE_O.VREGN.n14 XFE_O.VREGN.n6 11.1284
R5582 XFE_O.VREGN.n14 XFE_O.VREGN.n13 8.37084
R5583 XFE_O.VREGN.n1 XFE_O.VREGN.t7 5.73764
R5584 XFE_O.VREGN.n3 XFE_O.VREGN.t0 5.73764
R5585 XFE_O.VREGN.n9 XFE_O.VREGN.n7 5.51014
R5586 XFE_O.VREGN.n13 XFE_O.VREGN.n12 5.32067
R5587 XFE_O.VREGN.n11 XFE_O.VREGN.n10 5.32067
R5588 XFE_O.VREGN.n9 XFE_O.VREGN.n8 5.32067
R5589 XFE_O.VREGN.n1 XFE_O.VREGN.n0 5.32067
R5590 XFE_O.VREGN.n5 XFE_O.VREGN.n4 5.32067
R5591 XFE_O.VREGN.n3 XFE_O.VREGN.n2 5.32067
R5592 XFE_O.VREGN XFE_O.VREGN.n14 4.53963
R5593 XFE_O.VREGN.n12 XFE_O.VREGN.t14 0.228
R5594 XFE_O.VREGN.n12 XFE_O.VREGN.t15 0.228
R5595 XFE_O.VREGN.n10 XFE_O.VREGN.t12 0.228
R5596 XFE_O.VREGN.n10 XFE_O.VREGN.t13 0.228
R5597 XFE_O.VREGN.n8 XFE_O.VREGN.t10 0.228
R5598 XFE_O.VREGN.n8 XFE_O.VREGN.t11 0.228
R5599 XFE_O.VREGN.n7 XFE_O.VREGN.t8 0.228
R5600 XFE_O.VREGN.n7 XFE_O.VREGN.t9 0.228
R5601 XFE_O.VREGN.n0 XFE_O.VREGN.t5 0.228
R5602 XFE_O.VREGN.n0 XFE_O.VREGN.t6 0.228
R5603 XFE_O.VREGN.n4 XFE_O.VREGN.t3 0.228
R5604 XFE_O.VREGN.n4 XFE_O.VREGN.t4 0.228
R5605 XFE_O.VREGN.n2 XFE_O.VREGN.t1 0.228
R5606 XFE_O.VREGN.n2 XFE_O.VREGN.t2 0.228
R5607 XFE_O.VREGN.n5 XFE_O.VREGN.n3 0.189974
R5608 XFE_O.VREGN.n11 XFE_O.VREGN.n9 0.189974
R5609 XFE_O.VREGN.n13 XFE_O.VREGN.n11 0.189974
R5610 XFE_O.VREGN.n6 XFE_O.VREGN.n5 0.0952368
R5611 XFE_O.VREGN.n6 XFE_O.VREGN.n1 0.0952368
R5612 XFE_O.SB.n20 XFE_O.SB.t14 127.788
R5613 XFE_O.SB.n13 XFE_O.SB.t7 127.788
R5614 XFE_O.SB.t10 XFE_O.SB.n15 127.668
R5615 XFE_O.SB.n20 XFE_O.SB.t13 127.668
R5616 XFE_O.SB.t12 XFE_O.SB.n21 127.668
R5617 XFE_O.SB.n18 XFE_O.SB.t11 127.668
R5618 XFE_O.SB.n13 XFE_O.SB.t8 127.668
R5619 XFE_O.SB.n14 XFE_O.SB.t9 127.668
R5620 XFE_O.SB.t14 XFE_O.SB.n19 113.632
R5621 XFE_O.SB.n11 XFE_O.SB.t7 113.632
R5622 XFE_O.SB.n16 XFE_O.SB.t10 109.174
R5623 XFE_O.SB.t13 XFE_O.SB.n17 109.174
R5624 XFE_O.SB.n22 XFE_O.SB.t12 109.174
R5625 XFE_O.SB.n23 XFE_O.SB.t11 109.174
R5626 XFE_O.SB.t8 XFE_O.SB.n12 109.174
R5627 XFE_O.SB.t9 XFE_O.SB.n9 109.174
R5628 XFE_O.SB.n4 XFE_O.SB.t6 24.3193
R5629 XFE_O.SB.n16 XFE_O.SB.n7 18.4942
R5630 XFE_O.SB.n22 XFE_O.SB.n8 18.4942
R5631 XFE_O.SB.n24 XFE_O.SB.n23 18.4942
R5632 XFE_O.SB.n10 XFE_O.SB.n9 18.4942
R5633 XFE_O.SB.n5 XFE_O.SB.n4 16.5284
R5634 XFE_O.SB.n2 XFE_O.SB.n0 13.9299
R5635 XFE_O.SB.n23 XFE_O.SB.n22 11.6805
R5636 XFE_O.SB.n22 XFE_O.SB.n17 11.6805
R5637 XFE_O.SB.n23 XFE_O.SB.n16 11.6805
R5638 XFE_O.SB.n12 XFE_O.SB.n9 11.6805
R5639 XFE_O.SB.n16 XFE_O.SB.n9 11.6805
R5640 XFE_O.SB.n5 XFE_O.SB.n2 11.5728
R5641 XFE_O.SB.n26 XFE_O.SB.n6 10.8396
R5642 XFE_O.SB.n4 XFE_O.SB.n3 10.1049
R5643 XFE_O.SB.n26 XFE_O.SB.n25 9.0005
R5644 XFE_O.SB.n19 XFE_O.SB.n8 7.17687
R5645 XFE_O.SB.n11 XFE_O.SB.n10 7.17687
R5646 XFE_O.SB.n27 XFE_O.SB.n26 6.72479
R5647 XFE_O.SB.n27 XFE_O.SB.n5 6.33963
R5648 XFE_O.SB.n1 XFE_O.SB.t1 5.7796
R5649 XFE_O.SB.n0 XFE_O.SB.t2 5.73764
R5650 XFE_O.SB.n1 XFE_O.SB.t0 5.59012
R5651 XFE_O.SB.n0 XFE_O.SB.t3 5.54817
R5652 XFE_O.SB.n2 XFE_O.SB.n1 4.5005
R5653 XFE_O.SB.n19 XFE_O.SB.n17 4.42851
R5654 XFE_O.SB.n12 XFE_O.SB.n11 4.42851
R5655 XFE_O.SB.n3 XFE_O.SB.t5 0.228
R5656 XFE_O.SB.n3 XFE_O.SB.t4 0.228
R5657 XFE_O.SB.n10 XFE_O.SB.n7 0.1205
R5658 XFE_O.SB.n15 XFE_O.SB.n14 0.1205
R5659 XFE_O.SB.n14 XFE_O.SB.n13 0.1205
R5660 XFE_O.SB.n21 XFE_O.SB.n20 0.1205
R5661 XFE_O.SB.n21 XFE_O.SB.n18 0.1205
R5662 XFE_O.SB.n24 XFE_O.SB.n8 0.1205
R5663 XFE_O.SB.n25 XFE_O.SB.n7 0.0485
R5664 XFE_O.SB.n15 XFE_O.SB.n6 0.0485
R5665 XFE_O.SB.n18 XFE_O.SB.n6 0.0485
R5666 XFE_O.SB.n25 XFE_O.SB.n24 0.0485
R5667 XFE_O.SB XFE_O.SB.n27 0.0396304
R5668 XFE_O.SA.n14 XFE_O.SA.t14 127.788
R5669 XFE_O.SA.n7 XFE_O.SA.t7 127.788
R5670 XFE_O.SA.t10 XFE_O.SA.n9 127.668
R5671 XFE_O.SA.n14 XFE_O.SA.t13 127.668
R5672 XFE_O.SA.t12 XFE_O.SA.n15 127.668
R5673 XFE_O.SA.n12 XFE_O.SA.t11 127.668
R5674 XFE_O.SA.n7 XFE_O.SA.t8 127.668
R5675 XFE_O.SA.n8 XFE_O.SA.t9 127.668
R5676 XFE_O.SA.t14 XFE_O.SA.n13 113.632
R5677 XFE_O.SA.n5 XFE_O.SA.t7 113.632
R5678 XFE_O.SA.n10 XFE_O.SA.t10 109.174
R5679 XFE_O.SA.t13 XFE_O.SA.n11 109.174
R5680 XFE_O.SA.n16 XFE_O.SA.t12 109.174
R5681 XFE_O.SA.n17 XFE_O.SA.t11 109.174
R5682 XFE_O.SA.t8 XFE_O.SA.n6 109.174
R5683 XFE_O.SA.t9 XFE_O.SA.n3 109.174
R5684 XFE_O.SA.n22 XFE_O.SA.t6 22.3095
R5685 XFE_O.SA.n23 XFE_O.SA.n22 19.0355
R5686 XFE_O.SA.n10 XFE_O.SA.n1 18.4942
R5687 XFE_O.SA.n16 XFE_O.SA.n2 18.4942
R5688 XFE_O.SA.n18 XFE_O.SA.n17 18.4942
R5689 XFE_O.SA.n4 XFE_O.SA.n3 18.4942
R5690 XFE_O.SA.n26 XFE_O.SA.n24 14.1193
R5691 XFE_O.SA.n23 XFE_O.SA.n20 13.5922
R5692 XFE_O.SA.n17 XFE_O.SA.n16 11.6805
R5693 XFE_O.SA.n16 XFE_O.SA.n11 11.6805
R5694 XFE_O.SA.n17 XFE_O.SA.n10 11.6805
R5695 XFE_O.SA.n6 XFE_O.SA.n3 11.6805
R5696 XFE_O.SA.n10 XFE_O.SA.n3 11.6805
R5697 XFE_O.SA.n20 XFE_O.SA.n0 10.8396
R5698 XFE_O.SA.n27 XFE_O.SA.n26 9.71407
R5699 XFE_O.SA.n20 XFE_O.SA.n19 9.0005
R5700 XFE_O.SA.n13 XFE_O.SA.n2 7.17687
R5701 XFE_O.SA.n5 XFE_O.SA.n4 7.17687
R5702 XFE_O.SA.n25 XFE_O.SA.t1 5.7796
R5703 XFE_O.SA.n21 XFE_O.SA.t5 5.73764
R5704 XFE_O.SA.n24 XFE_O.SA.t3 5.73764
R5705 XFE_O.SA.n25 XFE_O.SA.t0 5.59012
R5706 XFE_O.SA.n21 XFE_O.SA.t4 5.54817
R5707 XFE_O.SA.n24 XFE_O.SA.t2 5.54817
R5708 XFE_O.SA.n22 XFE_O.SA.n21 4.73734
R5709 XFE_O.SA.n26 XFE_O.SA.n25 4.5005
R5710 XFE_O.SA.n13 XFE_O.SA.n11 4.42851
R5711 XFE_O.SA.n6 XFE_O.SA.n5 4.42851
R5712 XFE_O.SA.n27 XFE_O.SA.n23 2.54398
R5713 XFE_O.SA.n4 XFE_O.SA.n1 0.1205
R5714 XFE_O.SA.n9 XFE_O.SA.n8 0.1205
R5715 XFE_O.SA.n8 XFE_O.SA.n7 0.1205
R5716 XFE_O.SA.n15 XFE_O.SA.n14 0.1205
R5717 XFE_O.SA.n15 XFE_O.SA.n12 0.1205
R5718 XFE_O.SA.n18 XFE_O.SA.n2 0.1205
R5719 XFE_O.SA.n19 XFE_O.SA.n1 0.0485
R5720 XFE_O.SA.n9 XFE_O.SA.n0 0.0485
R5721 XFE_O.SA.n12 XFE_O.SA.n0 0.0485
R5722 XFE_O.SA.n19 XFE_O.SA.n18 0.0485
R5723 XFE_O.SA XFE_O.SA.n27 0.0396304
R5724 XFE_O.VREGP.n14 XFE_O.VREGP.n6 16.4697
R5725 XFE_O.VREGP.n14 XFE_O.VREGP.n13 12.6577
R5726 XFE_O.VREGP.n1 XFE_O.VREGP.t7 5.73764
R5727 XFE_O.VREGP.n5 XFE_O.VREGP.t0 5.73764
R5728 XFE_O.VREGP.n9 XFE_O.VREGP.n7 5.51014
R5729 XFE_O.VREGP.n9 XFE_O.VREGP.n8 5.32067
R5730 XFE_O.VREGP.n11 XFE_O.VREGP.n10 5.32067
R5731 XFE_O.VREGP.n13 XFE_O.VREGP.n12 5.32067
R5732 XFE_O.VREGP.n1 XFE_O.VREGP.n0 5.32067
R5733 XFE_O.VREGP.n3 XFE_O.VREGP.n2 5.32067
R5734 XFE_O.VREGP.n5 XFE_O.VREGP.n4 5.32067
R5735 XFE_O.VREGP.n7 XFE_O.VREGP.t14 0.228
R5736 XFE_O.VREGP.n7 XFE_O.VREGP.t15 0.228
R5737 XFE_O.VREGP.n8 XFE_O.VREGP.t12 0.228
R5738 XFE_O.VREGP.n8 XFE_O.VREGP.t13 0.228
R5739 XFE_O.VREGP.n10 XFE_O.VREGP.t10 0.228
R5740 XFE_O.VREGP.n10 XFE_O.VREGP.t11 0.228
R5741 XFE_O.VREGP.n12 XFE_O.VREGP.t8 0.228
R5742 XFE_O.VREGP.n12 XFE_O.VREGP.t9 0.228
R5743 XFE_O.VREGP.n0 XFE_O.VREGP.t5 0.228
R5744 XFE_O.VREGP.n0 XFE_O.VREGP.t6 0.228
R5745 XFE_O.VREGP.n2 XFE_O.VREGP.t3 0.228
R5746 XFE_O.VREGP.n2 XFE_O.VREGP.t4 0.228
R5747 XFE_O.VREGP.n4 XFE_O.VREGP.t1 0.228
R5748 XFE_O.VREGP.n4 XFE_O.VREGP.t2 0.228
R5749 XFE_O.VREGP.n3 XFE_O.VREGP.n1 0.189974
R5750 XFE_O.VREGP.n13 XFE_O.VREGP.n11 0.189974
R5751 XFE_O.VREGP.n11 XFE_O.VREGP.n9 0.189974
R5752 XFE_O.VREGP.n6 XFE_O.VREGP.n5 0.0952368
R5753 XFE_O.VREGP.n6 XFE_O.VREGP.n3 0.0952368
R5754 XFE_O.VREGP XFE_O.VREGP.n14 0.0396304
R5755 XFE_E.VREGP XFE_E.VREGP.n13 16.4305
R5756 XFE_E.VREGP XFE_E.VREGP.n6 12.6968
R5757 XFE_E.VREGP.n8 XFE_E.VREGP.t7 5.73764
R5758 XFE_E.VREGP.n10 XFE_E.VREGP.t0 5.73764
R5759 XFE_E.VREGP.n2 XFE_E.VREGP.n0 5.51014
R5760 XFE_E.VREGP.n6 XFE_E.VREGP.n5 5.32067
R5761 XFE_E.VREGP.n4 XFE_E.VREGP.n3 5.32067
R5762 XFE_E.VREGP.n2 XFE_E.VREGP.n1 5.32067
R5763 XFE_E.VREGP.n8 XFE_E.VREGP.n7 5.32067
R5764 XFE_E.VREGP.n12 XFE_E.VREGP.n11 5.32067
R5765 XFE_E.VREGP.n10 XFE_E.VREGP.n9 5.32067
R5766 XFE_E.VREGP.n5 XFE_E.VREGP.t14 0.228
R5767 XFE_E.VREGP.n5 XFE_E.VREGP.t15 0.228
R5768 XFE_E.VREGP.n3 XFE_E.VREGP.t12 0.228
R5769 XFE_E.VREGP.n3 XFE_E.VREGP.t13 0.228
R5770 XFE_E.VREGP.n1 XFE_E.VREGP.t10 0.228
R5771 XFE_E.VREGP.n1 XFE_E.VREGP.t11 0.228
R5772 XFE_E.VREGP.n0 XFE_E.VREGP.t8 0.228
R5773 XFE_E.VREGP.n0 XFE_E.VREGP.t9 0.228
R5774 XFE_E.VREGP.n7 XFE_E.VREGP.t5 0.228
R5775 XFE_E.VREGP.n7 XFE_E.VREGP.t6 0.228
R5776 XFE_E.VREGP.n11 XFE_E.VREGP.t3 0.228
R5777 XFE_E.VREGP.n11 XFE_E.VREGP.t4 0.228
R5778 XFE_E.VREGP.n9 XFE_E.VREGP.t1 0.228
R5779 XFE_E.VREGP.n9 XFE_E.VREGP.t2 0.228
R5780 XFE_E.VREGP.n12 XFE_E.VREGP.n10 0.189974
R5781 XFE_E.VREGP.n4 XFE_E.VREGP.n2 0.189974
R5782 XFE_E.VREGP.n6 XFE_E.VREGP.n4 0.189974
R5783 XFE_E.VREGP.n13 XFE_E.VREGP.n12 0.0952368
R5784 XFE_E.VREGP.n13 XFE_E.VREGP.n8 0.0952368
R5785 XFE_E.SA.n17 XFE_E.SA.t14 127.788
R5786 XFE_E.SA.n10 XFE_E.SA.t7 127.788
R5787 XFE_E.SA.t10 XFE_E.SA.n12 127.668
R5788 XFE_E.SA.n17 XFE_E.SA.t13 127.668
R5789 XFE_E.SA.t12 XFE_E.SA.n18 127.668
R5790 XFE_E.SA.n15 XFE_E.SA.t11 127.668
R5791 XFE_E.SA.n10 XFE_E.SA.t8 127.668
R5792 XFE_E.SA.n11 XFE_E.SA.t9 127.668
R5793 XFE_E.SA.t14 XFE_E.SA.n16 113.632
R5794 XFE_E.SA.n8 XFE_E.SA.t7 113.632
R5795 XFE_E.SA.n13 XFE_E.SA.t10 109.174
R5796 XFE_E.SA.t13 XFE_E.SA.n14 109.174
R5797 XFE_E.SA.n19 XFE_E.SA.t12 109.174
R5798 XFE_E.SA.n20 XFE_E.SA.t11 109.174
R5799 XFE_E.SA.t8 XFE_E.SA.n9 109.174
R5800 XFE_E.SA.t9 XFE_E.SA.n6 109.174
R5801 XFE_E.SA.n25 XFE_E.SA.t6 22.3095
R5802 XFE_E.SA.n26 XFE_E.SA.n25 19.0355
R5803 XFE_E.SA.n13 XFE_E.SA.n4 18.4942
R5804 XFE_E.SA.n19 XFE_E.SA.n5 18.4942
R5805 XFE_E.SA.n21 XFE_E.SA.n20 18.4942
R5806 XFE_E.SA.n7 XFE_E.SA.n6 18.4942
R5807 XFE_E.SA.n2 XFE_E.SA.n0 14.1193
R5808 XFE_E.SA.n26 XFE_E.SA.n23 13.5922
R5809 XFE_E.SA.n20 XFE_E.SA.n19 11.6805
R5810 XFE_E.SA.n19 XFE_E.SA.n14 11.6805
R5811 XFE_E.SA.n20 XFE_E.SA.n13 11.6805
R5812 XFE_E.SA.n9 XFE_E.SA.n6 11.6805
R5813 XFE_E.SA.n13 XFE_E.SA.n6 11.6805
R5814 XFE_E.SA.n23 XFE_E.SA.n3 10.8396
R5815 XFE_E.SA XFE_E.SA.n2 9.7532
R5816 XFE_E.SA.n23 XFE_E.SA.n22 9.0005
R5817 XFE_E.SA.n16 XFE_E.SA.n5 7.17687
R5818 XFE_E.SA.n8 XFE_E.SA.n7 7.17687
R5819 XFE_E.SA.n1 XFE_E.SA.t0 5.7796
R5820 XFE_E.SA.n24 XFE_E.SA.t4 5.73764
R5821 XFE_E.SA.n0 XFE_E.SA.t2 5.73764
R5822 XFE_E.SA.n1 XFE_E.SA.t1 5.59012
R5823 XFE_E.SA.n24 XFE_E.SA.t5 5.54817
R5824 XFE_E.SA.n0 XFE_E.SA.t3 5.54817
R5825 XFE_E.SA.n25 XFE_E.SA.n24 4.73734
R5826 XFE_E.SA.n2 XFE_E.SA.n1 4.5005
R5827 XFE_E.SA.n16 XFE_E.SA.n14 4.42851
R5828 XFE_E.SA.n9 XFE_E.SA.n8 4.42851
R5829 XFE_E.SA XFE_E.SA.n26 2.50485
R5830 XFE_E.SA.n7 XFE_E.SA.n4 0.1205
R5831 XFE_E.SA.n12 XFE_E.SA.n11 0.1205
R5832 XFE_E.SA.n11 XFE_E.SA.n10 0.1205
R5833 XFE_E.SA.n18 XFE_E.SA.n17 0.1205
R5834 XFE_E.SA.n18 XFE_E.SA.n15 0.1205
R5835 XFE_E.SA.n21 XFE_E.SA.n5 0.1205
R5836 XFE_E.SA.n22 XFE_E.SA.n4 0.0485
R5837 XFE_E.SA.n12 XFE_E.SA.n3 0.0485
R5838 XFE_E.SA.n15 XFE_E.SA.n3 0.0485
R5839 XFE_E.SA.n22 XFE_E.SA.n21 0.0485
R5840 XFE_E.SB.n14 XFE_E.SB.t14 127.788
R5841 XFE_E.SB.n7 XFE_E.SB.t7 127.788
R5842 XFE_E.SB.t10 XFE_E.SB.n9 127.668
R5843 XFE_E.SB.n14 XFE_E.SB.t13 127.668
R5844 XFE_E.SB.t12 XFE_E.SB.n15 127.668
R5845 XFE_E.SB.n12 XFE_E.SB.t11 127.668
R5846 XFE_E.SB.n7 XFE_E.SB.t8 127.668
R5847 XFE_E.SB.n8 XFE_E.SB.t9 127.668
R5848 XFE_E.SB.t14 XFE_E.SB.n13 113.632
R5849 XFE_E.SB.n5 XFE_E.SB.t7 113.632
R5850 XFE_E.SB.n10 XFE_E.SB.t10 109.174
R5851 XFE_E.SB.t13 XFE_E.SB.n11 109.174
R5852 XFE_E.SB.n16 XFE_E.SB.t12 109.174
R5853 XFE_E.SB.n17 XFE_E.SB.t11 109.174
R5854 XFE_E.SB.t8 XFE_E.SB.n6 109.174
R5855 XFE_E.SB.t9 XFE_E.SB.n3 109.174
R5856 XFE_E.SB.n25 XFE_E.SB.t6 24.3193
R5857 XFE_E.SB.n10 XFE_E.SB.n1 18.4942
R5858 XFE_E.SB.n16 XFE_E.SB.n2 18.4942
R5859 XFE_E.SB.n18 XFE_E.SB.n17 18.4942
R5860 XFE_E.SB.n4 XFE_E.SB.n3 18.4942
R5861 XFE_E.SB.n26 XFE_E.SB.n25 16.5284
R5862 XFE_E.SB.n23 XFE_E.SB.n21 13.9299
R5863 XFE_E.SB.n17 XFE_E.SB.n16 11.6805
R5864 XFE_E.SB.n16 XFE_E.SB.n11 11.6805
R5865 XFE_E.SB.n17 XFE_E.SB.n10 11.6805
R5866 XFE_E.SB.n6 XFE_E.SB.n3 11.6805
R5867 XFE_E.SB.n10 XFE_E.SB.n3 11.6805
R5868 XFE_E.SB.n26 XFE_E.SB.n23 11.5728
R5869 XFE_E.SB.n20 XFE_E.SB.n0 10.8396
R5870 XFE_E.SB.n25 XFE_E.SB.n24 10.1049
R5871 XFE_E.SB.n20 XFE_E.SB.n19 9.0005
R5872 XFE_E.SB.n13 XFE_E.SB.n2 7.17687
R5873 XFE_E.SB.n5 XFE_E.SB.n4 7.17687
R5874 XFE_E.SB XFE_E.SB.n20 6.76392
R5875 XFE_E.SB XFE_E.SB.n26 6.3005
R5876 XFE_E.SB.n22 XFE_E.SB.t0 5.7796
R5877 XFE_E.SB.n21 XFE_E.SB.t3 5.73764
R5878 XFE_E.SB.n22 XFE_E.SB.t1 5.59012
R5879 XFE_E.SB.n21 XFE_E.SB.t2 5.54817
R5880 XFE_E.SB.n23 XFE_E.SB.n22 4.5005
R5881 XFE_E.SB.n13 XFE_E.SB.n11 4.42851
R5882 XFE_E.SB.n6 XFE_E.SB.n5 4.42851
R5883 XFE_E.SB.n24 XFE_E.SB.t4 0.228
R5884 XFE_E.SB.n24 XFE_E.SB.t5 0.228
R5885 XFE_E.SB.n4 XFE_E.SB.n1 0.1205
R5886 XFE_E.SB.n9 XFE_E.SB.n8 0.1205
R5887 XFE_E.SB.n8 XFE_E.SB.n7 0.1205
R5888 XFE_E.SB.n15 XFE_E.SB.n14 0.1205
R5889 XFE_E.SB.n15 XFE_E.SB.n12 0.1205
R5890 XFE_E.SB.n18 XFE_E.SB.n2 0.1205
R5891 XFE_E.SB.n19 XFE_E.SB.n1 0.0485
R5892 XFE_E.SB.n9 XFE_E.SB.n0 0.0485
R5893 XFE_E.SB.n12 XFE_E.SB.n0 0.0485
R5894 XFE_E.SB.n19 XFE_E.SB.n18 0.0485
R5895 XFE_E.VREGN.n14 XFE_E.VREGN.n6 11.1284
R5896 XFE_E.VREGN.n14 XFE_E.VREGN.n13 8.37084
R5897 XFE_E.VREGN.n1 XFE_E.VREGN.t7 5.73764
R5898 XFE_E.VREGN.n5 XFE_E.VREGN.t0 5.73764
R5899 XFE_E.VREGN.n9 XFE_E.VREGN.n7 5.51014
R5900 XFE_E.VREGN.n9 XFE_E.VREGN.n8 5.32067
R5901 XFE_E.VREGN.n11 XFE_E.VREGN.n10 5.32067
R5902 XFE_E.VREGN.n13 XFE_E.VREGN.n12 5.32067
R5903 XFE_E.VREGN.n1 XFE_E.VREGN.n0 5.32067
R5904 XFE_E.VREGN.n3 XFE_E.VREGN.n2 5.32067
R5905 XFE_E.VREGN.n5 XFE_E.VREGN.n4 5.32067
R5906 XFE_E.VREGN XFE_E.VREGN.n14 4.53963
R5907 XFE_E.VREGN.n7 XFE_E.VREGN.t14 0.228
R5908 XFE_E.VREGN.n7 XFE_E.VREGN.t15 0.228
R5909 XFE_E.VREGN.n8 XFE_E.VREGN.t12 0.228
R5910 XFE_E.VREGN.n8 XFE_E.VREGN.t13 0.228
R5911 XFE_E.VREGN.n10 XFE_E.VREGN.t10 0.228
R5912 XFE_E.VREGN.n10 XFE_E.VREGN.t11 0.228
R5913 XFE_E.VREGN.n12 XFE_E.VREGN.t8 0.228
R5914 XFE_E.VREGN.n12 XFE_E.VREGN.t9 0.228
R5915 XFE_E.VREGN.n0 XFE_E.VREGN.t5 0.228
R5916 XFE_E.VREGN.n0 XFE_E.VREGN.t6 0.228
R5917 XFE_E.VREGN.n2 XFE_E.VREGN.t3 0.228
R5918 XFE_E.VREGN.n2 XFE_E.VREGN.t4 0.228
R5919 XFE_E.VREGN.n4 XFE_E.VREGN.t1 0.228
R5920 XFE_E.VREGN.n4 XFE_E.VREGN.t2 0.228
R5921 XFE_E.VREGN.n3 XFE_E.VREGN.n1 0.189974
R5922 XFE_E.VREGN.n13 XFE_E.VREGN.n11 0.189974
R5923 XFE_E.VREGN.n11 XFE_E.VREGN.n9 0.189974
R5924 XFE_E.VREGN.n6 XFE_E.VREGN.n5 0.0952368
R5925 XFE_E.VREGN.n6 XFE_E.VREGN.n3 0.0952368
C0 XFE_E.XN XFE_E.NREGEN 15.2443f
C1 O_REGEN_CLKB XFE_O.SXN 0.24469f
C2 E_REGEN_CLK FE_E_P 0.28385f
C3 E_REGEN_CLKB XFE_E.XN 0.27371f
C4 E_SENSE_CLK XFE_E.NREGEN 0.11224f
C5 XFE_O.SB XFE_O.NREGEN 2.22508f
C6 O_REGEN_CLK XFE_O.BN 0.12159f
C7 O_REGEN_CLKB XFE_O.SXP 0.14644f
C8 RX_BW_EN_N VTHN 0.52758f
C9 FE_E_P XFE_E.BN 3.20364f
C10 O_REGEN_CLK O_REGEN_CLKB 5.87024f
C11 E_SENSE_CLK E_REGEN_CLKB 0.01888f
C12 O_SENSE_CLK XFE_O.NTAIL 0.93342f
C13 SAMP_E_N XFE_E.NREGEN 0.0139f
C14 XFE_O.VREGN XFE_O.XN 9.76051f
C15 XFE_O.SA XFE_O.NREGEN 2.62097f
C16 O_REGEN_CLK XFE_O.SXN 0.28429f
C17 SAMP_E_P VDD 0.26142f
C18 XFE_E.XN XFE_E.XP 18.0183f
C19 XFE_O.SB XFE_O.XN 3.3005f
C20 XFE_O.VREGP XFE_O.NREGEN 0.01091f
C21 XFE_O.VREGN XFE_O.XP 1.71293f
C22 E_REGEN_CLK XFE_E.SA 0.34023f
C23 O_REGEN_CLK XFE_O.SXP 0.39898f
C24 VDD RX_RAWN 1.26797f
C25 VDD XFE_O.BN 6.76697f
C26 XFE_O.BP XFE_O.SXP 2.48339f
C27 O_SENSE_CLK O_SENSE_BOOST 4.27044f
C28 XFE_O.SA XFE_O.XN 2.02785f
C29 XFE_O.SB XFE_O.XP 2.02624f
C30 E_SENSE_CLK XFE_E.XP 0.15824f
C31 E_REGEN_CLK XFE_E.SB 0.27286f
C32 O_SENSE_CLK O_REGEN_CLKB 0.01888f
C33 FE_E_P E_REGEN_CLKB 0.19768f
C34 VDD O_REGEN_CLKB 17.4463f
C35 REST_BIAS VDD 0.20996f
C36 VDD XFE_O.SXN 12.5413f
C37 SAMP_E_P RX_RESTP 0.05468f
C38 SAMP_O_P SAMP_O_N 5.12811f
C39 SAMP_E_N RX_RESTN 0.21698f
C40 XFE_O.SA XFE_O.XP 2.75504f
C41 E_SENSE_CLK XFE_E.XN 1.26026f
C42 XFE_O.VREGP XFE_O.XN 1.41685f
C43 XFE_E.VREGP XFE_E.NREGEN 0.01091f
C44 VTHP VTHN 1.695f
C45 E_REGEN_CLKB XFE_E.VREGP 3.66341f
C46 VDD XFE_O.SXP 12.5687f
C47 SAMP_E_N XFE_E.XN 0.02387f
C48 VDD TERM_EN5_N 1.84084f
C49 XFE_E.SA XFE_E.NREGEN 2.62097f
C50 XFE_O.VREGP XFE_O.XP 9.69939f
C51 O_REGEN_CLK O_SENSE_CLK 0.05769f
C52 O_REGEN_CLK VDD 21.5719f
C53 RX_RAWN RX_BW_EN_N 0.3734f
C54 E_REGEN_CLKB XFE_E.SA 0.23634f
C55 VDD XFE_O.BP 6.76837f
C56 XFE_E.SB XFE_E.NREGEN 2.22508f
C57 E_SENSE_CLK SAMP_E_N 0.30032f
C58 E_REGEN_CLKB XFE_E.SB 0.16909f
C59 VDD XFE_E.BP 6.76837f
C60 XFE_E.SXP XFE_E.BP 2.48339f
C61 SAMP_E_P E_SENSE_BOOST 0.06659f
C62 XFE_E.VREGP XFE_E.XP 9.69939f
C63 RXP TERM_EN5_N 0.3225f
C64 SAMP_O_P XFE_O.NREGEN 0.0139f
C65 E_SENSE_BOOST XFE_E.NTAIL 0.96944f
C66 VDD TERM_EN3_N 1.84084f
C67 E_REGEN_CLKB XFE_E.VREGN 2.28169f
C68 O_SENSE_CLK VDD 3.1142f
C69 VDD XFE_E.SXP 12.5687f
C70 XFE_E.SA XFE_E.XP 2.75504f
C71 XFE_O.SA XFE_O.SB 4.61805f
C72 XFE_E.VREGP XFE_E.XN 1.41685f
C73 VDD XFE_E.SXN 12.5413f
C74 XFE_E.SA XFE_E.XN 2.02785f
C75 XFE_E.SB XFE_E.XP 2.02624f
C76 SAMP_O_P XFE_O.XN 0.02387f
C77 RXP TERM_EN3_N 0.3225f
C78 XFE_O.VREGP XFE_O.SA 0.01053f
C79 VDD RXP 0.72204f
C80 XFE_E.VREGN XFE_E.XP 1.71293f
C81 XFE_E.SB XFE_E.XN 3.3005f
C82 E_SENSE_CLK XFE_E.SA 2.78252f
C83 VDD TERM_EN1_N 1.84084f
C84 RX_RESTP VDD 0.38423f
C85 SAMP_E_N XFE_E.SA 0.90873f
C86 XFE_E.VREGN XFE_E.XN 9.76051f
C87 VDD RX_BW_EN_N 3.19847f
C88 E_SENSE_CLK XFE_E.SB 1.27971f
C89 SAMP_O_P RX_RESTN 0.17429f
C90 SAMP_E_N XFE_E.SB 0.04213f
C91 RXP TERM_EN1_N 0.30522f
C92 VDD E_CAPTURE_CLKB 0.11035f
C93 SAMP_O_N XFE_O.NTAIL 1.30545f
C94 XFE_E.SA XFE_E.VREGP 0.01053f
C95 SAMP_O_P XFE_O.SB 0.04213f
C96 VDD VTHP 0.93005f
C97 SAMP_O_P XFE_O.SA 0.90873f
C98 VDD O_CAPTURE_CLKB 0.11035f
C99 SAMP_O_N O_SENSE_BOOST 0.06659f
C100 XFE_E.SB XFE_E.SA 4.61805f
C101 E_REGEN_CLK XFE_E.NTAIL 0.05461f
C102 RX_RESTN SAMP_CLK_N 0.09294f
C103 XFE_O.NREGEN XFE_O.NTAIL 0.05705f
C104 RX_BW_EN_N VTHP 0.14804f
C105 SAMP_E_P XFE_E.NREGEN 0.01317f
C106 XFE_E.NREGEN XFE_E.NTAIL 0.05705f
C107 O_REGEN_CLKB XFE_O.NREGEN 0.18411f
C108 XFE_O.NREGEN XFE_O.SXN 1.12793f
C109 RX_RESTN SAMP_BIAS 0.01215f
C110 O_SENSE_CLK SAMP_O_N 5.05623f
C111 SAMP_O_N VDD 0.35499f
C112 RXP RXN 0.49155f
C113 XFE_O.NREGEN XFE_O.SXP 0.43552f
C114 O_REGEN_CLK XFE_O.NREGEN 2.24204f
C115 SAMP_E_P RX_RESTN 0.42621f
C116 SAMP_E_P XFE_E.XP 0.01394f
C117 O_REGEN_CLKB XFE_O.XN 0.27371f
C118 E_REGEN_CLK VDD 21.5719f
C119 XFE_O.XN XFE_O.SXN 1.52306f
C120 E_REGEN_CLK XFE_E.SXP 0.39898f
C121 O_REGEN_CLKB XFE_O.XP 0.41303f
C122 VDD XFE_E.BN 6.76697f
C123 XFE_O.XP XFE_O.SXN 0.18968f
C124 E_REGEN_CLK XFE_E.SXN 0.28429f
C125 SAMP_O_N RX_RESTP 0.21629f
C126 O_REGEN_CLK XFE_O.XN 2.93387f
C127 E_SENSE_CLK SAMP_E_P 5.05623f
C128 O_SENSE_CLK XFE_O.NREGEN 0.11224f
C129 VDD XFE_O.NREGEN 9.02169f
C130 XFE_E.BN XFE_E.SXN 2.55502f
C131 XFE_O.SB XFE_O.NTAIL 2.81419f
C132 XFE_O.XP XFE_O.SXP 2.28757f
C133 E_SENSE_CLK XFE_E.NTAIL 0.93342f
C134 O_REGEN_CLK XFE_O.XP 2.97989f
C135 TERM_EN6_N TERM_EN5_N 0.0465f
C136 SAMP_E_P SAMP_E_N 5.05443f
C137 VDD XFE_E.NREGEN 9.02169f
C138 SAMP_E_N XFE_E.NTAIL 1.1378f
C139 XFE_O.SA XFE_O.NTAIL 3.62199f
C140 XFE_E.NREGEN XFE_E.SXP 0.43552f
C141 O_REGEN_CLKB XFE_O.VREGN 2.28169f
C142 VDD E_REGEN_CLKB 17.4463f
C143 E_REGEN_CLKB XFE_E.SXP 0.14644f
C144 O_SENSE_CLK XFE_O.XN 1.26026f
C145 VDD XFE_O.XN 23.0487f
C146 XFE_O.VREGN XFE_O.SXN 0.01502f
C147 XFE_E.NREGEN XFE_E.SXN 1.12793f
C148 O_SENSE_BOOST XFE_O.SB 0.17061f
C149 O_REGEN_CLKB XFE_O.SB 0.16909f
C150 E_REGEN_CLKB XFE_E.SXN 0.24469f
C151 O_SENSE_CLK XFE_O.XP 0.15824f
C152 VDD XFE_O.XP 24.8188f
C153 TERM_EN5_N TERM_EN4_N 0.0465f
C154 VDD TERM_EN6_N 1.78028f
C155 O_SENSE_BOOST XFE_O.SA 0.04435f
C156 O_REGEN_CLKB XFE_O.SA 0.23634f
C157 RX_RESTN VDD 0.41275f
C158 VDD XFE_E.XP 24.8188f
C159 XFE_E.XP XFE_E.SXP 2.28757f
C160 XFE_O.SB XFE_O.SXP 0.01479f
C161 O_REGEN_CLK XFE_O.SB 0.27286f
C162 SAMP_CLK_P SAMP_CLK_N 2.34225f
C163 SAMP_E_P XFE_E.SA 0.05427f
C164 O_REGEN_CLKB XFE_O.VREGP 3.66341f
C165 VDD XFE_E.XN 23.0487f
C166 XFE_E.SA XFE_E.NTAIL 3.62199f
C167 XFE_E.XP XFE_E.SXN 0.18968f
C168 O_REGEN_CLK XFE_O.SA 0.34023f
C169 RXP TERM_EN6_N 0.32905f
C170 RX_BIAS RXP 0.89265f
C171 SAMP_E_P XFE_E.SB 0.77892f
C172 TERM_EN4_N TERM_EN3_N 0.0465f
C173 VDD TERM_EN4_N 1.84084f
C174 E_SENSE_CLK VDD 3.1142f
C175 VDD XFE_O.VREGN 12.591f
C176 XFE_O.VREGP XFE_O.SXP 0.03789f
C177 XFE_E.XN XFE_E.SXN 1.52306f
C178 XFE_E.SB XFE_E.NTAIL 2.81419f
C179 RX_RESTN RX_RESTP 4.19071f
C180 O_SENSE_CLK XFE_O.SB 1.27971f
C181 SAMP_E_N VDD 0.26142f
C182 VDD XFE_O.SB 6.44275f
C183 SAMP_O_P XFE_O.NTAIL 1.1378f
C184 O_SENSE_CLK XFE_O.SA 2.78252f
C185 VDD XFE_O.SA 7.16352f
C186 SAMP_CLK_P SAMP_BIAS 2.0425f
C187 RXP TERM_EN4_N 0.3225f
C188 TERM_EN3_N TERM_EN2_N 0.0465f
C189 VDD TERM_EN2_N 1.84084f
C190 FE_E_P VDD 11.6793f
C191 VDD XFE_O.VREGP 13.9312f
C192 SAMP_O_P O_SENSE_BOOST 0.05905f
C193 SAMP_E_N RX_RESTP 0.17266f
C194 FE_E_P XFE_E.SXN 0.13551f
C195 VDD XFE_E.VREGP 13.9312f
C196 XFE_E.VREGP XFE_E.SXP 0.03789f
C197 RXP TERM_EN2_N 0.3225f
C198 VDD XFE_E.SA 7.16352f
C199 TERM_EN2_N TERM_EN1_N 0.0465f
C200 VDD TERM_EN0_N 1.71963f
C201 RX_RAWP RX_RAWN 0.58235f
C202 E_SENSE_CLK E_SENSE_BOOST 4.27044f
C203 FE_E_N XFE_E.BP 2.97395f
C204 SAMP_CLK_N SAMP_BIAS 1.47664f
C205 VDD XFE_E.SB 6.44275f
C206 XFE_E.SB XFE_E.SXP 0.01479f
C207 SAMP_E_N E_SENSE_BOOST 0.05905f
C208 FE_E_N VDD 11.5691f
C209 REST_BIAS RX_RAWP 0.25868f
C210 SAMP_O_N XFE_O.NREGEN 0.01317f
C211 VDD XFE_E.VREGN 12.591f
C212 E_REGEN_CLK XFE_E.BN 0.12159f
C213 RXP TERM_EN0_N 0.29398f
C214 TERM_EN1_N TERM_EN0_N 0.0465f
C215 VDD E_CAPTURE_CLK 0.11499f
C216 XFE_E.VREGN XFE_E.SXN 0.01502f
C217 RX_BIAS RXN 0.36689f
C218 O_SENSE_CLK SAMP_O_P 0.30032f
C219 SAMP_O_P VDD 0.35499f
C220 FE_O_P XFE_O.BP 2.97395f
C221 E_REGEN_CLK XFE_E.NREGEN 2.24204f
C222 FE_O_N XFE_O.BN 3.20364f
C223 SAMP_O_N XFE_O.XP 0.01394f
C224 E_REGEN_CLK E_REGEN_CLKB 5.87024f
C225 FE_O_N O_REGEN_CLKB 0.19768f
C226 VDD O_CAPTURE_CLK 0.11499f
C227 E_SENSE_BOOST XFE_E.SA 0.04435f
C228 FE_O_P VDD 11.5691f
C229 FE_O_N XFE_O.SXN 0.13551f
C230 SAMP_O_P RX_RESTP 0.10098f
C231 SAMP_O_N RX_RESTN 0.01966f
C232 E_REGEN_CLKB XFE_E.BN 0.10264f
C233 VDD RX_RAWP 1.26797f
C234 E_SENSE_BOOST XFE_E.SB 0.17061f
C235 O_REGEN_CLK FE_O_N 0.28385f
C236 XFE_O.XN XFE_O.NREGEN 15.2443f
C237 E_REGEN_CLK XFE_E.XP 2.97989f
C238 RX_RESTP SAMP_CLK_P 0.38527f
C239 SAMP_E_P XFE_E.NTAIL 1.30545f
C240 E_REGEN_CLKB XFE_E.NREGEN 0.18411f
C241 XFE_O.XP XFE_O.NREGEN 15.5907f
C242 E_REGEN_CLK XFE_E.XN 2.93387f
C243 O_SENSE_BOOST XFE_O.NTAIL 0.96944f
C244 SAMP_O_N XFE_O.SB 0.77892f
C245 RX_RAWP RX_BW_EN_N 0.3734f
C246 E_REGEN_CLK E_SENSE_CLK 0.05769f
C247 VDD VTHN 0.51765f
C248 FE_O_N VDD 11.6793f
C249 SAMP_O_N XFE_O.SA 0.05427f
C250 XFE_O.XP XFE_O.XN 18.0183f
C251 XFE_E.XP XFE_E.NREGEN 15.5907f
C252 O_REGEN_CLK XFE_O.NTAIL 0.05461f
C253 REST_BIAS RX_RAWN 0.11711f
C254 O_REGEN_CLKB XFE_O.BN 0.10264f
C255 E_REGEN_CLKB XFE_E.XP 0.41303f
C256 RX_RESTP SAMP_CLK_N 0.02351f
C257 XFE_O.SXN XFE_O.BN 2.55502f
C258 O_CAPTURE_CLK VSS 0.14336f
C259 O_CAPTURE_CLKB VSS 0.14751f
C260 E_CAPTURE_CLK VSS 0.14336f
C261 E_CAPTURE_CLKB VSS 0.14751f
C262 TERM_EN0_N VSS 3.16281f
C263 TERM_EN1_N VSS 2.58106f
C264 TERM_EN2_N VSS 2.56583f
C265 TERM_EN3_N VSS 2.56561f
C266 TERM_EN4_N VSS 2.56561f
C267 TERM_EN5_N VSS 2.56561f
C268 TERM_EN6_N VSS 2.69513f
C269 RXN VSS 15.24638f
C270 RXP VSS 15.17772f
C271 RX_BIAS VSS 13.3368f
C272 VTHN VSS 5.17466f
C273 VTHP VSS 5.04058f
C274 RX_BW_EN_N VSS 4.30524f
C275 RX_RAWN VSS 11.07534f
C276 RX_RAWP VSS 11.20287f
C277 REST_BIAS VSS 10.07665f
C278 SAMP_BIAS VSS 13.87178f
C279 SAMP_CLK_N VSS 9.98147f
C280 SAMP_CLK_P VSS 14.21055f
C281 RX_RESTP VSS 14.02047f
C282 RX_RESTN VSS 13.0766f
C283 O_SENSE_BOOST VSS 7.77216f
C284 SAMP_O_N VSS 23.62455f
C285 SAMP_O_P VSS 21.78122f
C286 E_SENSE_BOOST VSS 7.77215f
C287 SAMP_E_N VSS 21.54272f
C288 SAMP_E_P VSS 23.6221f
C289 FE_O_N VSS 9.55872f
C290 FE_O_P VSS 9.7944f
C291 FE_E_N VSS 9.7944f
C292 FE_E_P VSS 9.55872f
C293 O_SENSE_CLK VSS 10.59916f
C294 E_SENSE_CLK VSS 10.59916f
C295 O_REGEN_CLK VSS 13.63236f
C296 E_REGEN_CLK VSS 13.63236f
C297 O_REGEN_CLKB VSS 4.43319f
C298 E_REGEN_CLKB VSS 4.43319f
C299 VDD VSS 3.25549p
C300 XFE_O.NTAIL VSS 14.09834f
C301 XFE_E.NTAIL VSS 14.6349f
C302 XFE_O.BN VSS 15.10208f
C303 XFE_O.SXN VSS 12.96782f
C304 XFE_O.SXP VSS 13.11247f
C305 XFE_O.BP VSS 14.72881f
C306 XFE_E.BP VSS 15.07135f
C307 XFE_E.SXP VSS 14.89757f
C308 XFE_E.SXN VSS 13.51859f
C309 XFE_E.BN VSS 15.5139f
C310 XFE_O.NREGEN VSS 16.31945f
C311 XFE_E.NREGEN VSS 16.79713f
C312 XFE_O.XN VSS 8.1339f
C313 XFE_O.XP VSS 8.86716f
C314 XFE_E.XP VSS 9.30753f
C315 XFE_E.XN VSS 9.22271f
C316 XFE_O.VREGN VSS 0.31123f
C317 XFE_O.SB VSS 9.74535f
C318 XFE_O.SA VSS 10.5446f
C319 XFE_O.VREGP VSS 0.30873f
C320 XFE_E.VREGP VSS 2.16504f
C321 XFE_E.SA VSS 11.29091f
C322 XFE_E.SB VSS 11.02386f
C323 XFE_E.VREGN VSS 0.31123f
C324 XFE_E.VREGN.t7 VSS 2.0543f
C325 XFE_E.VREGN.t6 VSS 0.43767f
C326 XFE_E.VREGN.t5 VSS 0.43767f
C327 XFE_E.VREGN.n0 VSS 1.55201f
C328 XFE_E.VREGN.n1 VSS 0.85309f
C329 XFE_E.VREGN.t4 VSS 0.43767f
C330 XFE_E.VREGN.t3 VSS 0.43767f
C331 XFE_E.VREGN.n2 VSS 1.55201f
C332 XFE_E.VREGN.n3 VSS 0.35769f
C333 XFE_E.VREGN.t0 VSS 2.05061f
C334 XFE_E.VREGN.t2 VSS 0.43767f
C335 XFE_E.VREGN.t1 VSS 0.43767f
C336 XFE_E.VREGN.n4 VSS 1.55201f
C337 XFE_E.VREGN.n5 VSS 0.76545f
C338 XFE_E.VREGN.n6 VSS 0.70781f
C339 XFE_E.VREGN.t15 VSS 0.44748f
C340 XFE_E.VREGN.t14 VSS 0.44357f
C341 XFE_E.VREGN.n7 VSS 1.56416f
C342 XFE_E.VREGN.t13 VSS 0.44357f
C343 XFE_E.VREGN.t12 VSS 0.44357f
C344 XFE_E.VREGN.n8 VSS 1.55201f
C345 XFE_E.VREGN.n9 VSS 0.78649f
C346 XFE_E.VREGN.t11 VSS 0.44357f
C347 XFE_E.VREGN.t10 VSS 0.44357f
C348 XFE_E.VREGN.n10 VSS 1.55201f
C349 XFE_E.VREGN.n11 VSS 0.44533f
C350 XFE_E.VREGN.t9 VSS 0.44357f
C351 XFE_E.VREGN.t8 VSS 0.44357f
C352 XFE_E.VREGN.n12 VSS 1.55201f
C353 XFE_E.VREGN.n13 VSS 1.47521f
C354 XFE_E.VREGN.n14 VSS 1.97789f
C355 XFE_E.SB.n0 VSS 0.13155f
C356 XFE_E.SB.n1 VSS 0.08021f
C357 XFE_E.SB.n2 VSS 0.2771f
C358 XFE_E.SB.n3 VSS 0.14681f
C359 XFE_E.SB.n4 VSS 0.2771f
C360 XFE_E.SB.n5 VSS 0.13697f
C361 XFE_E.SB.n6 VSS 0.14681f
C362 XFE_E.SB.n7 VSS 0.40649f
C363 XFE_E.SB.n8 VSS 0.20576f
C364 XFE_E.SB.n9 VSS 0.19077f
C365 XFE_E.SB.n10 VSS 0.14681f
C366 XFE_E.SB.n11 VSS 0.14681f
C367 XFE_E.SB.n12 VSS 0.19077f
C368 XFE_E.SB.n13 VSS 0.13697f
C369 XFE_E.SB.n14 VSS 0.40649f
C370 XFE_E.SB.n15 VSS 0.20576f
C371 XFE_E.SB.n16 VSS 0.14681f
C372 XFE_E.SB.n17 VSS 0.14681f
C373 XFE_E.SB.n18 VSS 0.08021f
C374 XFE_E.SB.n19 VSS 0.06663f
C375 XFE_E.SB.n20 VSS 0.97831f
C376 XFE_E.SB.t3 VSS 1.23317f
C377 XFE_E.SB.t2 VSS 1.22543f
C378 XFE_E.SB.n21 VSS 1.08915f
C379 XFE_E.SB.t0 VSS 1.13745f
C380 XFE_E.SB.t1 VSS 1.12965f
C381 XFE_E.SB.n22 VSS 0.46789f
C382 XFE_E.SB.n23 VSS 1.54724f
C383 XFE_E.SB.t6 VSS 2.07955f
C384 XFE_E.SB.t5 VSS 0.33146f
C385 XFE_E.SB.t4 VSS 0.33143f
C386 XFE_E.SB.n24 VSS 1.07064f
C387 XFE_E.SB.n25 VSS 2.8859f
C388 XFE_E.SB.n26 VSS 2.7955f
C389 XFE_E.SA.t2 VSS 1.28668f
C390 XFE_E.SA.t3 VSS 1.27847f
C391 XFE_E.SA.n0 VSS 1.33857f
C392 XFE_E.SA.t0 VSS 1.17333f
C393 XFE_E.SA.t1 VSS 1.16514f
C394 XFE_E.SA.n1 VSS 0.49128f
C395 XFE_E.SA.n2 VSS 1.53905f
C396 XFE_E.SA.n3 VSS 0.13813f
C397 XFE_E.SA.n4 VSS 0.08422f
C398 XFE_E.SA.n5 VSS 0.29096f
C399 XFE_E.SA.n6 VSS 0.15416f
C400 XFE_E.SA.n7 VSS 0.29096f
C401 XFE_E.SA.n8 VSS 0.14381f
C402 XFE_E.SA.n9 VSS 0.15416f
C403 XFE_E.SA.n10 VSS 0.42682f
C404 XFE_E.SA.n11 VSS 0.21605f
C405 XFE_E.SA.n12 VSS 0.20031f
C406 XFE_E.SA.n13 VSS 0.15416f
C407 XFE_E.SA.n14 VSS 0.15416f
C408 XFE_E.SA.n15 VSS 0.20031f
C409 XFE_E.SA.n16 VSS 0.14381f
C410 XFE_E.SA.n17 VSS 0.42682f
C411 XFE_E.SA.n18 VSS 0.21605f
C412 XFE_E.SA.n19 VSS 0.15416f
C413 XFE_E.SA.n20 VSS 0.15416f
C414 XFE_E.SA.n21 VSS 0.08422f
C415 XFE_E.SA.n22 VSS 0.06997f
C416 XFE_E.SA.n23 VSS 1.7301f
C417 XFE_E.SA.t6 VSS 2.08471f
C418 XFE_E.SA.t4 VSS 1.28664f
C419 XFE_E.SA.t5 VSS 1.27851f
C420 XFE_E.SA.n24 VSS 0.7353f
C421 XFE_E.SA.n25 VSS 2.83246f
C422 XFE_E.SA.n26 VSS 3.35641f
C423 XFE_E.VREGP.t9 VSS 0.46595f
C424 XFE_E.VREGP.t8 VSS 0.46998f
C425 XFE_E.VREGP.n0 VSS 1.65721f
C426 XFE_E.VREGP.t11 VSS 0.46595f
C427 XFE_E.VREGP.t10 VSS 0.46595f
C428 XFE_E.VREGP.n1 VSS 1.64434f
C429 XFE_E.VREGP.n2 VSS 0.83328f
C430 XFE_E.VREGP.t13 VSS 0.46595f
C431 XFE_E.VREGP.t12 VSS 0.46595f
C432 XFE_E.VREGP.n3 VSS 1.64434f
C433 XFE_E.VREGP.n4 VSS 0.47183f
C434 XFE_E.VREGP.t15 VSS 0.46998f
C435 XFE_E.VREGP.t14 VSS 0.46595f
C436 XFE_E.VREGP.n5 VSS 1.64434f
C437 XFE_E.VREGP.n6 VSS 2.2363f
C438 XFE_E.VREGP.t7 VSS 2.16809f
C439 XFE_E.VREGP.t6 VSS 0.45551f
C440 XFE_E.VREGP.t5 VSS 0.45551f
C441 XFE_E.VREGP.n7 VSS 1.64434f
C442 XFE_E.VREGP.n8 VSS 0.81098f
C443 XFE_E.VREGP.t0 VSS 2.16809f
C444 XFE_E.VREGP.t2 VSS 0.45551f
C445 XFE_E.VREGP.t1 VSS 0.45551f
C446 XFE_E.VREGP.n9 VSS 1.64434f
C447 XFE_E.VREGP.n10 VSS 0.90384f
C448 XFE_E.VREGP.t4 VSS 0.45551f
C449 XFE_E.VREGP.t3 VSS 0.45551f
C450 XFE_E.VREGP.n11 VSS 1.64434f
C451 XFE_E.VREGP.n12 VSS 0.37897f
C452 XFE_E.VREGP.n13 VSS 1.21829f
C453 XFE_O.VREGP.t7 VSS 2.16809f
C454 XFE_O.VREGP.t6 VSS 0.45551f
C455 XFE_O.VREGP.t5 VSS 0.45551f
C456 XFE_O.VREGP.n0 VSS 1.64434f
C457 XFE_O.VREGP.n1 VSS 0.90384f
C458 XFE_O.VREGP.t4 VSS 0.45551f
C459 XFE_O.VREGP.t3 VSS 0.45551f
C460 XFE_O.VREGP.n2 VSS 1.64434f
C461 XFE_O.VREGP.n3 VSS 0.37897f
C462 XFE_O.VREGP.t0 VSS 2.16809f
C463 XFE_O.VREGP.t2 VSS 0.45551f
C464 XFE_O.VREGP.t1 VSS 0.45551f
C465 XFE_O.VREGP.n4 VSS 1.64434f
C466 XFE_O.VREGP.n5 VSS 0.81098f
C467 XFE_O.VREGP.n6 VSS 1.22138f
C468 XFE_O.VREGP.t15 VSS 0.46998f
C469 XFE_O.VREGP.t14 VSS 0.46595f
C470 XFE_O.VREGP.n7 VSS 1.65721f
C471 XFE_O.VREGP.t13 VSS 0.46595f
C472 XFE_O.VREGP.t12 VSS 0.46595f
C473 XFE_O.VREGP.n8 VSS 1.64434f
C474 XFE_O.VREGP.n9 VSS 0.83328f
C475 XFE_O.VREGP.t11 VSS 0.46595f
C476 XFE_O.VREGP.t10 VSS 0.46595f
C477 XFE_O.VREGP.n10 VSS 1.64434f
C478 XFE_O.VREGP.n11 VSS 0.47183f
C479 XFE_O.VREGP.t9 VSS 0.46595f
C480 XFE_O.VREGP.t8 VSS 0.46998f
C481 XFE_O.VREGP.n12 VSS 1.64434f
C482 XFE_O.VREGP.n13 VSS 2.23447f
C483 XFE_O.VREGP.n14 VSS 1.85505f
C484 XFE_O.SA.n0 VSS 0.13813f
C485 XFE_O.SA.n1 VSS 0.08422f
C486 XFE_O.SA.n2 VSS 0.29096f
C487 XFE_O.SA.n3 VSS 0.15416f
C488 XFE_O.SA.n4 VSS 0.29096f
C489 XFE_O.SA.n5 VSS 0.14381f
C490 XFE_O.SA.n6 VSS 0.15416f
C491 XFE_O.SA.n7 VSS 0.42682f
C492 XFE_O.SA.n8 VSS 0.21605f
C493 XFE_O.SA.n9 VSS 0.20031f
C494 XFE_O.SA.n10 VSS 0.15416f
C495 XFE_O.SA.n11 VSS 0.15416f
C496 XFE_O.SA.n12 VSS 0.20031f
C497 XFE_O.SA.n13 VSS 0.14381f
C498 XFE_O.SA.n14 VSS 0.42682f
C499 XFE_O.SA.n15 VSS 0.21605f
C500 XFE_O.SA.n16 VSS 0.15416f
C501 XFE_O.SA.n17 VSS 0.15416f
C502 XFE_O.SA.n18 VSS 0.08422f
C503 XFE_O.SA.n19 VSS 0.06997f
C504 XFE_O.SA.n20 VSS 1.7301f
C505 XFE_O.SA.t6 VSS 2.0847f
C506 XFE_O.SA.t5 VSS 1.28664f
C507 XFE_O.SA.t4 VSS 1.27851f
C508 XFE_O.SA.n21 VSS 0.7353f
C509 XFE_O.SA.n22 VSS 2.83246f
C510 XFE_O.SA.n23 VSS 3.3642f
C511 XFE_O.SA.t3 VSS 1.28668f
C512 XFE_O.SA.t2 VSS 1.27847f
C513 XFE_O.SA.n24 VSS 1.33857f
C514 XFE_O.SA.t1 VSS 1.17349f
C515 XFE_O.SA.t0 VSS 1.1653f
C516 XFE_O.SA.n25 VSS 0.49128f
C517 XFE_O.SA.n26 VSS 1.53799f
C518 XFE_O.SA.n27 VSS 0.73959f
C519 XFE_O.SB.t2 VSS 1.23317f
C520 XFE_O.SB.t3 VSS 1.22543f
C521 XFE_O.SB.n0 VSS 1.08915f
C522 XFE_O.SB.t1 VSS 1.13739f
C523 XFE_O.SB.t0 VSS 1.12959f
C524 XFE_O.SB.n1 VSS 0.46789f
C525 XFE_O.SB.n2 VSS 1.54724f
C526 XFE_O.SB.t6 VSS 2.07955f
C527 XFE_O.SB.t4 VSS 0.33143f
C528 XFE_O.SB.t5 VSS 0.33146f
C529 XFE_O.SB.n3 VSS 1.07064f
C530 XFE_O.SB.n4 VSS 2.8859f
C531 XFE_O.SB.n5 VSS 2.80291f
C532 XFE_O.SB.n6 VSS 0.13155f
C533 XFE_O.SB.n7 VSS 0.08021f
C534 XFE_O.SB.n8 VSS 0.2771f
C535 XFE_O.SB.n9 VSS 0.14681f
C536 XFE_O.SB.n10 VSS 0.2771f
C537 XFE_O.SB.n11 VSS 0.13697f
C538 XFE_O.SB.n12 VSS 0.14681f
C539 XFE_O.SB.n13 VSS 0.40649f
C540 XFE_O.SB.n14 VSS 0.20576f
C541 XFE_O.SB.n15 VSS 0.19077f
C542 XFE_O.SB.n16 VSS 0.14681f
C543 XFE_O.SB.n17 VSS 0.14681f
C544 XFE_O.SB.n18 VSS 0.19077f
C545 XFE_O.SB.n19 VSS 0.13697f
C546 XFE_O.SB.n20 VSS 0.40649f
C547 XFE_O.SB.n21 VSS 0.20576f
C548 XFE_O.SB.n22 VSS 0.14681f
C549 XFE_O.SB.n23 VSS 0.14681f
C550 XFE_O.SB.n24 VSS 0.08021f
C551 XFE_O.SB.n25 VSS 0.06663f
C552 XFE_O.SB.n26 VSS 0.97774f
C553 XFE_O.SB.n27 VSS 1.27166f
C554 XFE_O.VREGN.t7 VSS 2.05061f
C555 XFE_O.VREGN.t6 VSS 0.43767f
C556 XFE_O.VREGN.t5 VSS 0.43767f
C557 XFE_O.VREGN.n0 VSS 1.55201f
C558 XFE_O.VREGN.n1 VSS 0.76545f
C559 XFE_O.VREGN.t0 VSS 2.0543f
C560 XFE_O.VREGN.t2 VSS 0.43767f
C561 XFE_O.VREGN.t1 VSS 0.43767f
C562 XFE_O.VREGN.n2 VSS 1.55201f
C563 XFE_O.VREGN.n3 VSS 0.85309f
C564 XFE_O.VREGN.t4 VSS 0.43767f
C565 XFE_O.VREGN.t3 VSS 0.43767f
C566 XFE_O.VREGN.n4 VSS 1.55201f
C567 XFE_O.VREGN.n5 VSS 0.35769f
C568 XFE_O.VREGN.n6 VSS 0.70781f
C569 XFE_O.VREGN.t9 VSS 0.44357f
C570 XFE_O.VREGN.t8 VSS 0.44748f
C571 XFE_O.VREGN.n7 VSS 1.56416f
C572 XFE_O.VREGN.t11 VSS 0.44357f
C573 XFE_O.VREGN.t10 VSS 0.44357f
C574 XFE_O.VREGN.n8 VSS 1.55201f
C575 XFE_O.VREGN.n9 VSS 0.78649f
C576 XFE_O.VREGN.t13 VSS 0.44357f
C577 XFE_O.VREGN.t12 VSS 0.44357f
C578 XFE_O.VREGN.n10 VSS 1.55201f
C579 XFE_O.VREGN.n11 VSS 0.44533f
C580 XFE_O.VREGN.t15 VSS 0.44357f
C581 XFE_O.VREGN.t14 VSS 0.44357f
C582 XFE_O.VREGN.n12 VSS 1.55201f
C583 XFE_O.VREGN.n13 VSS 1.47521f
C584 XFE_O.VREGN.n14 VSS 1.97789f
C585 XFE_E.XN.n0 VSS 0.18804f
C586 XFE_E.XN.n1 VSS 0.38313f
C587 XFE_E.XN.n2 VSS 0.13428f
C588 XFE_E.XN.n3 VSS 0.2094f
C589 XFE_E.XN.n4 VSS 0.19535f
C590 XFE_E.XN.n5 VSS 0.57977f
C591 XFE_E.XN.n6 VSS 0.28137f
C592 XFE_E.XN.n7 VSS 0.2094f
C593 XFE_E.XN.n8 VSS 0.2094f
C594 XFE_E.XN.n9 VSS 0.2639f
C595 XFE_E.XN.n10 VSS 0.29196f
C596 XFE_E.XN.n11 VSS 0.29347f
C597 XFE_E.XN.n12 VSS 0.57977f
C598 XFE_E.XN.n13 VSS 0.19535f
C599 XFE_E.XN.n14 VSS 0.39522f
C600 XFE_E.XN.n15 VSS 0.2094f
C601 XFE_E.XN.n16 VSS 0.2094f
C602 XFE_E.XN.n17 VSS 0.2094f
C603 XFE_E.XN.n18 VSS 0.10621f
C604 XFE_E.XN.n19 VSS 0.09546f
C605 XFE_E.XN.n20 VSS 1.55365f
C606 XFE_E.XN.n21 VSS 0.19535f
C607 XFE_E.XN.n22 VSS 0.2094f
C608 XFE_E.XN.n23 VSS 0.1979f
C609 XFE_E.XN.n24 VSS 1.02723f
C610 XFE_E.XN.n25 VSS 1.79502f
C611 XFE_E.XN.n26 VSS 0.10621f
C612 XFE_E.XN.n27 VSS 0.2094f
C613 XFE_E.XN.n28 VSS 0.39522f
C614 XFE_E.XN.n29 VSS 0.19535f
C615 XFE_E.XN.n30 VSS 0.2094f
C616 XFE_E.XN.n31 VSS 0.2094f
C617 XFE_E.XN.n32 VSS 0.2094f
C618 XFE_E.XN.n33 VSS 0.13579f
C619 XFE_E.XN.n34 VSS 0.13579f
C620 XFE_E.XN.n35 VSS 0.13428f
C621 XFE_E.XN.n36 VSS 0.2094f
C622 XFE_E.XN.n37 VSS 0.2094f
C623 XFE_E.XN.n38 VSS 0.19839f
C624 XFE_E.XN.n39 VSS 0.25314f
C625 XFE_E.XN.t4 VSS 1.6344f
C626 XFE_E.XN.t1 VSS 0.34825f
C627 XFE_E.XN.t0 VSS 0.34825f
C628 XFE_E.XN.n40 VSS 1.22847f
C629 XFE_E.XN.n41 VSS 0.62246f
C630 XFE_E.XN.t5 VSS 1.6344f
C631 XFE_E.XN.t23 VSS 0.34825f
C632 XFE_E.XN.t2 VSS 0.34825f
C633 XFE_E.XN.n42 VSS 1.22847f
C634 XFE_E.XN.n43 VSS 0.69235f
C635 XFE_E.XN.t3 VSS 0.34825f
C636 XFE_E.XN.t22 VSS 0.34825f
C637 XFE_E.XN.n44 VSS 1.22847f
C638 XFE_E.XN.n45 VSS 0.29435f
C639 XFE_E.XN.n46 VSS 0.21105f
C640 XFE_E.XN.n47 VSS 0.39522f
C641 XFE_E.XN.n48 VSS 0.19535f
C642 XFE_E.XN.n49 VSS 0.2094f
C643 XFE_E.XN.n50 VSS 0.2094f
C644 XFE_E.XN.n51 VSS 0.1979f
C645 XFE_E.XN.n52 VSS 0.3206f
C646 XFE_E.XN.n53 VSS 0.71021f
C647 XFE_E.XN.n54 VSS 0.87854f
C648 XFE_E.XN.t24 VSS 1.67287f
C649 XFE_E.XN.t34 VSS 0.38283f
C650 XFE_E.XN.t33 VSS 0.38283f
C651 XFE_E.XN.n55 VSS 1.2376f
C652 XFE_E.XN.n56 VSS 0.68027f
C653 XFE_E.XN.t26 VSS 0.38283f
C654 XFE_E.XN.t25 VSS 0.38283f
C655 XFE_E.XN.n57 VSS 1.2376f
C656 XFE_E.XN.n58 VSS 0.33764f
C657 XFE_E.XN.t29 VSS 1.66897f
C658 XFE_E.XN.t28 VSS 0.38283f
C659 XFE_E.XN.t27 VSS 0.38283f
C660 XFE_E.XN.n59 VSS 1.2376f
C661 XFE_E.XN.n60 VSS 0.55796f
C662 XFE_E.XN.n61 VSS 0.69915f
C663 XFE_E.XN.t31 VSS 0.4361f
C664 XFE_E.XN.t30 VSS 0.4361f
C665 XFE_E.XN.n62 VSS 1.23836f
C666 XFE_E.XN.t32 VSS 1.71194f
C667 XFE_E.XN.n63 VSS 0.969f
C668 XFE_E.XN.n64 VSS 1.90694f
C669 XFE_E.XN.n65 VSS 1.38561f
C670 XFE_E.XN.t13 VSS 1.62729f
C671 XFE_E.XN.t6 VSS 1.63007f
C672 XFE_E.XN.t8 VSS 0.34116f
C673 XFE_E.XN.t7 VSS 0.34116f
C674 XFE_E.XN.n66 VSS 1.2376f
C675 XFE_E.XN.n67 VSS 0.68027f
C676 XFE_E.XN.t10 VSS 0.34116f
C677 XFE_E.XN.t9 VSS 0.34116f
C678 XFE_E.XN.n68 VSS 1.2376f
C679 XFE_E.XN.n69 VSS 0.35512f
C680 XFE_E.XN.t12 VSS 0.34116f
C681 XFE_E.XN.t11 VSS 0.34116f
C682 XFE_E.XN.n70 VSS 1.2376f
C683 XFE_E.XN.n71 VSS 1.93393f
C684 XFE_E.XN.n72 VSS 2.19485f
C685 XFE_E.XN.t21 VSS 0.34116f
C686 XFE_E.XN.t20 VSS 0.34116f
C687 XFE_E.XN.n73 VSS 1.24729f
C688 XFE_E.XN.t19 VSS 0.34116f
C689 XFE_E.XN.t18 VSS 0.34116f
C690 XFE_E.XN.n74 VSS 1.2376f
C691 XFE_E.XN.n75 VSS 0.62716f
C692 XFE_E.XN.t17 VSS 0.34116f
C693 XFE_E.XN.t16 VSS 0.34116f
C694 XFE_E.XN.n76 VSS 1.2376f
C695 XFE_E.XN.n77 VSS 0.28523f
C696 XFE_E.XN.t15 VSS 0.34116f
C697 XFE_E.XN.t14 VSS 0.34393f
C698 XFE_E.XN.n78 VSS 1.2413f
C699 XFE_E.XN.n79 VSS 1.39559f
C700 XFE_E.XN.n80 VSS 2.5705f
C701 XFE_E.XP.n0 VSS 0.13162f
C702 XFE_E.XP.n1 VSS 0.13162f
C703 XFE_E.XP.n2 VSS 0.13162f
C704 XFE_E.XP.n3 VSS 0.13162f
C705 XFE_E.XP.n4 VSS 0.38311f
C706 XFE_E.XP.n5 VSS 0.18936f
C707 XFE_E.XP.n6 VSS 0.20298f
C708 XFE_E.XP.n7 VSS 0.20298f
C709 XFE_E.XP.n8 VSS 0.20298f
C710 XFE_E.XP.n9 VSS 0.20298f
C711 XFE_E.XP.n10 VSS 0.20298f
C712 XFE_E.XP.n11 VSS 0.20298f
C713 XFE_E.XP.n12 VSS 0.19184f
C714 XFE_E.XP.n13 VSS 0.36751f
C715 XFE_E.XP.t1 VSS 1.5824f
C716 XFE_E.XP.t0 VSS 0.33573f
C717 XFE_E.XP.t3 VSS 0.33573f
C718 XFE_E.XP.n14 VSS 1.19081f
C719 XFE_E.XP.n15 VSS 0.60338f
C720 XFE_E.XP.t31 VSS 1.5824f
C721 XFE_E.XP.t4 VSS 0.33573f
C722 XFE_E.XP.t10 VSS 0.33573f
C723 XFE_E.XP.n16 VSS 1.19081f
C724 XFE_E.XP.n17 VSS 0.67112f
C725 XFE_E.XP.t13 VSS 0.33573f
C726 XFE_E.XP.t34 VSS 0.33573f
C727 XFE_E.XP.n18 VSS 1.19081f
C728 XFE_E.XP.n19 VSS 0.28533f
C729 XFE_E.XP.n20 VSS 0.20458f
C730 XFE_E.XP.n21 VSS 0.38311f
C731 XFE_E.XP.n22 VSS 0.18936f
C732 XFE_E.XP.n23 VSS 0.20298f
C733 XFE_E.XP.n24 VSS 0.20298f
C734 XFE_E.XP.n25 VSS 0.19184f
C735 XFE_E.XP.n26 VSS 0.51601f
C736 XFE_E.XP.n27 VSS 0.65345f
C737 XFE_E.XP.n28 VSS 0.71994f
C738 XFE_E.XP.n29 VSS 0.75743f
C739 XFE_E.XP.n30 VSS 0.13162f
C740 XFE_E.XP.n31 VSS 0.13162f
C741 XFE_E.XP.n32 VSS 0.13162f
C742 XFE_E.XP.n33 VSS 0.13162f
C743 XFE_E.XP.n34 VSS 0.38311f
C744 XFE_E.XP.n35 VSS 0.28447f
C745 XFE_E.XP.n36 VSS 0.28447f
C746 XFE_E.XP.n37 VSS 0.28447f
C747 XFE_E.XP.n38 VSS 0.28447f
C748 XFE_E.XP.n39 VSS 0.28447f
C749 XFE_E.XP.n40 VSS 0.562f
C750 XFE_E.XP.n41 VSS 0.18936f
C751 XFE_E.XP.n42 VSS 0.20298f
C752 XFE_E.XP.n43 VSS 0.20298f
C753 XFE_E.XP.n44 VSS 0.20298f
C754 XFE_E.XP.n45 VSS 0.20298f
C755 XFE_E.XP.n46 VSS 0.20298f
C756 XFE_E.XP.n47 VSS 0.20298f
C757 XFE_E.XP.n48 VSS 0.19184f
C758 XFE_E.XP.n49 VSS 0.51601f
C759 XFE_E.XP.n50 VSS 1.57338f
C760 XFE_E.XP.n51 VSS 0.18936f
C761 XFE_E.XP.n52 VSS 0.20298f
C762 XFE_E.XP.n53 VSS 0.19184f
C763 XFE_E.XP.n54 VSS 0.96466f
C764 XFE_E.XP.n55 VSS 2.41464f
C765 XFE_E.XP.t15 VSS 1.58053f
C766 XFE_E.XP.t27 VSS 0.33383f
C767 XFE_E.XP.t26 VSS 0.33383f
C768 XFE_E.XP.n56 VSS 1.19966f
C769 XFE_E.XP.t14 VSS 1.58331f
C770 XFE_E.XP.t17 VSS 0.33383f
C771 XFE_E.XP.t16 VSS 0.33383f
C772 XFE_E.XP.n57 VSS 1.19966f
C773 XFE_E.XP.n58 VSS 0.65942f
C774 XFE_E.XP.t29 VSS 0.33383f
C775 XFE_E.XP.t28 VSS 0.33383f
C776 XFE_E.XP.n59 VSS 1.19966f
C777 XFE_E.XP.n60 VSS 0.34423f
C778 XFE_E.XP.n61 VSS 1.91833f
C779 XFE_E.XP.n62 VSS 3.62399f
C780 XFE_E.XP.t25 VSS 1.58331f
C781 XFE_E.XP.t24 VSS 0.33383f
C782 XFE_E.XP.t23 VSS 0.33383f
C783 XFE_E.XP.n63 VSS 1.19966f
C784 XFE_E.XP.n64 VSS 0.65942f
C785 XFE_E.XP.t22 VSS 0.33383f
C786 XFE_E.XP.t21 VSS 0.33383f
C787 XFE_E.XP.n65 VSS 1.19966f
C788 XFE_E.XP.n66 VSS 0.34423f
C789 XFE_E.XP.t18 VSS 1.58053f
C790 XFE_E.XP.t20 VSS 0.33383f
C791 XFE_E.XP.t19 VSS 0.33383f
C792 XFE_E.XP.n67 VSS 1.19966f
C793 XFE_E.XP.n68 VSS 1.91833f
C794 XFE_E.XP.n69 VSS 2.33527f
C795 XFE_E.XP.t12 VSS 1.63078f
C796 XFE_E.XP.t5 VSS 0.38004f
C797 XFE_E.XP.t32 VSS 0.38004f
C798 XFE_E.XP.n70 VSS 1.19966f
C799 XFE_E.XP.n71 VSS 0.65942f
C800 XFE_E.XP.t9 VSS 0.38004f
C801 XFE_E.XP.t30 VSS 0.38004f
C802 XFE_E.XP.n72 VSS 1.19966f
C803 XFE_E.XP.n73 VSS 0.34423f
C804 XFE_E.XP.t11 VSS 0.38004f
C805 XFE_E.XP.t6 VSS 0.38004f
C806 XFE_E.XP.n74 VSS 1.19966f
C807 XFE_E.XP.n75 VSS 0.34423f
C808 XFE_E.XP.t8 VSS 1.62002f
C809 XFE_E.XP.n76 VSS 1.13469f
C810 XFE_E.XP.t33 VSS 0.435f
C811 XFE_E.XP.t7 VSS 0.435f
C812 XFE_E.XP.n77 VSS 1.2004f
C813 XFE_E.XP.t2 VSS 1.67197f
C814 XFE_E.XP.n78 VSS 0.90508f
C815 XFE_E.XP.n79 VSS 1.85329f
C816 XFE_E.XP.n80 VSS 1.03535f
C817 XFE_O.XP.n0 VSS 0.75743f
C818 XFE_O.XP.n1 VSS 0.13162f
C819 XFE_O.XP.n2 VSS 0.20298f
C820 XFE_O.XP.n3 VSS 0.28447f
C821 XFE_O.XP.n4 VSS 0.20298f
C822 XFE_O.XP.n5 VSS 0.13162f
C823 XFE_O.XP.n6 VSS 0.18936f
C824 XFE_O.XP.n7 VSS 0.20298f
C825 XFE_O.XP.n8 VSS 0.562f
C826 XFE_O.XP.n9 VSS 0.28447f
C827 XFE_O.XP.n10 VSS 0.20298f
C828 XFE_O.XP.n11 VSS 0.38311f
C829 XFE_O.XP.n12 VSS 0.13162f
C830 XFE_O.XP.n13 VSS 0.13162f
C831 XFE_O.XP.n14 VSS 0.20298f
C832 XFE_O.XP.n15 VSS 0.28447f
C833 XFE_O.XP.n16 VSS 0.28447f
C834 XFE_O.XP.n17 VSS 0.28447f
C835 XFE_O.XP.n18 VSS 0.20298f
C836 XFE_O.XP.n19 VSS 0.19184f
C837 XFE_O.XP.n20 VSS 0.51601f
C838 XFE_O.XP.n21 VSS 1.57338f
C839 XFE_O.XP.n22 VSS 0.18936f
C840 XFE_O.XP.n23 VSS 0.20298f
C841 XFE_O.XP.n24 VSS 0.19184f
C842 XFE_O.XP.n25 VSS 0.96466f
C843 XFE_O.XP.n26 VSS 2.41464f
C844 XFE_O.XP.t21 VSS 1.58331f
C845 XFE_O.XP.t20 VSS 0.33383f
C846 XFE_O.XP.t19 VSS 0.33383f
C847 XFE_O.XP.n27 VSS 1.19966f
C848 XFE_O.XP.n28 VSS 0.65942f
C849 XFE_O.XP.t18 VSS 0.33383f
C850 XFE_O.XP.t17 VSS 0.33383f
C851 XFE_O.XP.n29 VSS 1.19966f
C852 XFE_O.XP.n30 VSS 0.34423f
C853 XFE_O.XP.t16 VSS 0.33383f
C854 XFE_O.XP.t15 VSS 0.33383f
C855 XFE_O.XP.n31 VSS 1.19966f
C856 XFE_O.XP.t14 VSS 1.58053f
C857 XFE_O.XP.n32 VSS 1.91833f
C858 XFE_O.XP.n33 VSS 3.62399f
C859 XFE_O.XP.t13 VSS 1.58053f
C860 XFE_O.XP.t6 VSS 1.58331f
C861 XFE_O.XP.t8 VSS 0.33383f
C862 XFE_O.XP.t7 VSS 0.33383f
C863 XFE_O.XP.n34 VSS 1.19966f
C864 XFE_O.XP.n35 VSS 0.65942f
C865 XFE_O.XP.t10 VSS 0.33383f
C866 XFE_O.XP.t9 VSS 0.33383f
C867 XFE_O.XP.n36 VSS 1.19966f
C868 XFE_O.XP.n37 VSS 0.34423f
C869 XFE_O.XP.t12 VSS 0.33383f
C870 XFE_O.XP.t11 VSS 0.33383f
C871 XFE_O.XP.n38 VSS 1.19966f
C872 XFE_O.XP.n39 VSS 1.91833f
C873 XFE_O.XP.n40 VSS 2.33527f
C874 XFE_O.XP.t25 VSS 1.63078f
C875 XFE_O.XP.t30 VSS 0.38004f
C876 XFE_O.XP.t29 VSS 0.38004f
C877 XFE_O.XP.n41 VSS 1.19966f
C878 XFE_O.XP.n42 VSS 0.65942f
C879 XFE_O.XP.t24 VSS 0.38004f
C880 XFE_O.XP.t23 VSS 0.38004f
C881 XFE_O.XP.n43 VSS 1.19966f
C882 XFE_O.XP.n44 VSS 0.34423f
C883 XFE_O.XP.t28 VSS 0.38004f
C884 XFE_O.XP.t27 VSS 0.38004f
C885 XFE_O.XP.n45 VSS 1.19966f
C886 XFE_O.XP.n46 VSS 0.34423f
C887 XFE_O.XP.t26 VSS 1.62002f
C888 XFE_O.XP.n47 VSS 1.13469f
C889 XFE_O.XP.t33 VSS 0.435f
C890 XFE_O.XP.t32 VSS 0.435f
C891 XFE_O.XP.n48 VSS 1.2004f
C892 XFE_O.XP.t31 VSS 1.67197f
C893 XFE_O.XP.n49 VSS 0.90508f
C894 XFE_O.XP.n50 VSS 1.85329f
C895 XFE_O.XP.n51 VSS 1.0456f
C896 XFE_O.XP.n52 VSS 0.13162f
C897 XFE_O.XP.n53 VSS 0.20298f
C898 XFE_O.XP.n54 VSS 0.38311f
C899 XFE_O.XP.n55 VSS 0.18936f
C900 XFE_O.XP.n56 VSS 0.20298f
C901 XFE_O.XP.n57 VSS 0.20298f
C902 XFE_O.XP.n58 VSS 0.20298f
C903 XFE_O.XP.n59 VSS 0.13162f
C904 XFE_O.XP.n60 VSS 0.13162f
C905 XFE_O.XP.n61 VSS 0.13162f
C906 XFE_O.XP.n62 VSS 0.20298f
C907 XFE_O.XP.n63 VSS 0.20298f
C908 XFE_O.XP.n64 VSS 0.19184f
C909 XFE_O.XP.n65 VSS 0.36751f
C910 XFE_O.XP.t4 VSS 1.5824f
C911 XFE_O.XP.t5 VSS 0.33573f
C912 XFE_O.XP.t34 VSS 0.33573f
C913 XFE_O.XP.n66 VSS 1.19081f
C914 XFE_O.XP.n67 VSS 0.67112f
C915 XFE_O.XP.t2 VSS 0.33573f
C916 XFE_O.XP.t1 VSS 0.33573f
C917 XFE_O.XP.n68 VSS 1.19081f
C918 XFE_O.XP.n69 VSS 0.28533f
C919 XFE_O.XP.t22 VSS 1.5824f
C920 XFE_O.XP.t0 VSS 0.33573f
C921 XFE_O.XP.t3 VSS 0.33573f
C922 XFE_O.XP.n70 VSS 1.19081f
C923 XFE_O.XP.n71 VSS 0.60338f
C924 XFE_O.XP.n72 VSS 0.20458f
C925 XFE_O.XP.n73 VSS 0.38311f
C926 XFE_O.XP.n74 VSS 0.18936f
C927 XFE_O.XP.n75 VSS 0.20298f
C928 XFE_O.XP.n76 VSS 0.20298f
C929 XFE_O.XP.n77 VSS 0.19184f
C930 XFE_O.XP.n78 VSS 0.51601f
C931 XFE_O.XP.n79 VSS 0.65345f
C932 XFE_O.XP.n80 VSS 0.71951f
C933 XFE_O.XP.n81 VSS 0.43054f
C934 XFE_O.XN.n0 VSS 0.19839f
C935 XFE_O.XN.n1 VSS 0.13428f
C936 XFE_O.XN.n2 VSS 0.13579f
C937 XFE_O.XN.n3 VSS 0.13579f
C938 XFE_O.XN.n4 VSS 0.39522f
C939 XFE_O.XN.n5 VSS 0.19535f
C940 XFE_O.XN.n6 VSS 0.2094f
C941 XFE_O.XN.n7 VSS 0.2094f
C942 XFE_O.XN.n8 VSS 0.2094f
C943 XFE_O.XN.n9 VSS 0.2094f
C944 XFE_O.XN.n10 VSS 0.2094f
C945 XFE_O.XN.n11 VSS 0.2094f
C946 XFE_O.XN.n12 VSS 0.10621f
C947 XFE_O.XN.n13 VSS 0.25314f
C948 XFE_O.XN.t1 VSS 1.6344f
C949 XFE_O.XN.t6 VSS 0.34825f
C950 XFE_O.XN.t2 VSS 0.34825f
C951 XFE_O.XN.n14 VSS 1.22847f
C952 XFE_O.XN.n15 VSS 0.69235f
C953 XFE_O.XN.t5 VSS 0.34825f
C954 XFE_O.XN.t0 VSS 0.34825f
C955 XFE_O.XN.n16 VSS 1.22847f
C956 XFE_O.XN.n17 VSS 0.29435f
C957 XFE_O.XN.t4 VSS 1.6344f
C958 XFE_O.XN.t23 VSS 0.34825f
C959 XFE_O.XN.t3 VSS 0.34825f
C960 XFE_O.XN.n18 VSS 1.22847f
C961 XFE_O.XN.n19 VSS 0.62246f
C962 XFE_O.XN.n20 VSS 0.21105f
C963 XFE_O.XN.n21 VSS 0.39522f
C964 XFE_O.XN.n22 VSS 0.19535f
C965 XFE_O.XN.n23 VSS 0.2094f
C966 XFE_O.XN.n24 VSS 0.2094f
C967 XFE_O.XN.n25 VSS 0.1979f
C968 XFE_O.XN.n26 VSS 0.3206f
C969 XFE_O.XN.n27 VSS 0.71021f
C970 XFE_O.XN.n28 VSS 0.87854f
C971 XFE_O.XN.t31 VSS 1.66897f
C972 XFE_O.XN.t26 VSS 0.38283f
C973 XFE_O.XN.t27 VSS 0.38283f
C974 XFE_O.XN.n29 VSS 1.2376f
C975 XFE_O.XN.n30 VSS 0.55796f
C976 XFE_O.XN.t28 VSS 1.67287f
C977 XFE_O.XN.t24 VSS 0.38283f
C978 XFE_O.XN.t25 VSS 0.38283f
C979 XFE_O.XN.n31 VSS 1.2376f
C980 XFE_O.XN.n32 VSS 0.68027f
C981 XFE_O.XN.t29 VSS 0.38283f
C982 XFE_O.XN.t30 VSS 0.38283f
C983 XFE_O.XN.n33 VSS 1.2376f
C984 XFE_O.XN.n34 VSS 0.33764f
C985 XFE_O.XN.n35 VSS 0.69915f
C986 XFE_O.XN.t33 VSS 0.4361f
C987 XFE_O.XN.t34 VSS 0.4361f
C988 XFE_O.XN.n36 VSS 1.23836f
C989 XFE_O.XN.t32 VSS 1.71194f
C990 XFE_O.XN.n37 VSS 0.969f
C991 XFE_O.XN.n38 VSS 1.90694f
C992 XFE_O.XN.n39 VSS 1.38561f
C993 XFE_O.XN.t14 VSS 1.63007f
C994 XFE_O.XN.t13 VSS 0.34116f
C995 XFE_O.XN.t12 VSS 0.34116f
C996 XFE_O.XN.n40 VSS 1.2376f
C997 XFE_O.XN.n41 VSS 0.68027f
C998 XFE_O.XN.t11 VSS 0.34116f
C999 XFE_O.XN.t10 VSS 0.34116f
C1000 XFE_O.XN.n42 VSS 1.2376f
C1001 XFE_O.XN.n43 VSS 0.35512f
C1002 XFE_O.XN.t7 VSS 1.62729f
C1003 XFE_O.XN.t9 VSS 0.34116f
C1004 XFE_O.XN.t8 VSS 0.34116f
C1005 XFE_O.XN.n44 VSS 1.2376f
C1006 XFE_O.XN.n45 VSS 1.93393f
C1007 XFE_O.XN.n46 VSS 2.19485f
C1008 XFE_O.XN.t22 VSS 0.34393f
C1009 XFE_O.XN.t21 VSS 0.34116f
C1010 XFE_O.XN.n47 VSS 1.2413f
C1011 XFE_O.XN.t16 VSS 0.34116f
C1012 XFE_O.XN.t15 VSS 0.34116f
C1013 XFE_O.XN.n48 VSS 1.24729f
C1014 XFE_O.XN.t18 VSS 0.34116f
C1015 XFE_O.XN.t17 VSS 0.34116f
C1016 XFE_O.XN.n49 VSS 1.2376f
C1017 XFE_O.XN.n50 VSS 0.62716f
C1018 XFE_O.XN.t20 VSS 0.34116f
C1019 XFE_O.XN.t19 VSS 0.34116f
C1020 XFE_O.XN.n51 VSS 1.2376f
C1021 XFE_O.XN.n52 VSS 0.28523f
C1022 XFE_O.XN.n53 VSS 1.39559f
C1023 XFE_O.XN.n54 VSS 2.58108f
C1024 XFE_O.XN.n55 VSS 0.18804f
C1025 XFE_O.XN.n56 VSS 0.10621f
C1026 XFE_O.XN.n57 VSS 0.19535f
C1027 XFE_O.XN.n58 VSS 0.2094f
C1028 XFE_O.XN.n59 VSS 0.2094f
C1029 XFE_O.XN.n60 VSS 0.57977f
C1030 XFE_O.XN.n61 VSS 0.13428f
C1031 XFE_O.XN.n62 VSS 0.39522f
C1032 XFE_O.XN.n63 VSS 0.19535f
C1033 XFE_O.XN.n64 VSS 0.2094f
C1034 XFE_O.XN.n65 VSS 0.2094f
C1035 XFE_O.XN.n66 VSS 0.29347f
C1036 XFE_O.XN.n67 VSS 0.29196f
C1037 XFE_O.XN.n68 VSS 0.2639f
C1038 XFE_O.XN.n69 VSS 0.2094f
C1039 XFE_O.XN.n70 VSS 0.57977f
C1040 XFE_O.XN.n71 VSS 0.28137f
C1041 XFE_O.XN.n72 VSS 0.2094f
C1042 XFE_O.XN.n73 VSS 0.38313f
C1043 XFE_O.XN.n74 VSS 0.09546f
C1044 XFE_O.XN.n75 VSS 1.55364f
C1045 XFE_O.XN.n76 VSS 0.19535f
C1046 XFE_O.XN.n77 VSS 0.2094f
C1047 XFE_O.XN.n78 VSS 0.1979f
C1048 XFE_O.XN.n79 VSS 1.02723f
C1049 XFE_O.XN.n80 VSS 1.79458f
C1050 XFE_O.XN.n81 VSS 1.07867f
C1051 XFE_E.NREGEN.t17 VSS 1.49452f
C1052 XFE_E.NREGEN.t16 VSS 1.4847f
C1053 XFE_E.NREGEN.n0 VSS 1.51825f
C1054 XFE_E.NREGEN.t2 VSS 0.31872f
C1055 XFE_E.NREGEN.t1 VSS 0.31589f
C1056 XFE_E.NREGEN.n1 VSS 1.09768f
C1057 XFE_E.NREGEN.t7 VSS 0.31589f
C1058 XFE_E.NREGEN.t13 VSS 0.31589f
C1059 XFE_E.NREGEN.n2 VSS 1.08892f
C1060 XFE_E.NREGEN.n3 VSS 0.57192f
C1061 XFE_E.NREGEN.t33 VSS 0.31589f
C1062 XFE_E.NREGEN.t8 VSS 0.31589f
C1063 XFE_E.NREGEN.n4 VSS 1.08892f
C1064 XFE_E.NREGEN.t11 VSS 0.31589f
C1065 XFE_E.NREGEN.t28 VSS 0.31872f
C1066 XFE_E.NREGEN.n5 VSS 1.09768f
C1067 XFE_E.NREGEN.n6 VSS 0.62125f
C1068 XFE_E.NREGEN.n7 VSS 1.81763f
C1069 XFE_E.NREGEN.t15 VSS 1.49452f
C1070 XFE_E.NREGEN.t14 VSS 1.4847f
C1071 XFE_E.NREGEN.n8 VSS 1.51825f
C1072 XFE_E.NREGEN.t9 VSS 0.32406f
C1073 XFE_E.NREGEN.t4 VSS 0.32109f
C1074 XFE_E.NREGEN.n9 VSS 1.09768f
C1075 XFE_E.NREGEN.t0 VSS 0.32109f
C1076 XFE_E.NREGEN.t6 VSS 0.32109f
C1077 XFE_E.NREGEN.n10 VSS 1.08892f
C1078 XFE_E.NREGEN.n11 VSS 0.57192f
C1079 XFE_E.NREGEN.t26 VSS 0.32109f
C1080 XFE_E.NREGEN.t27 VSS 0.32109f
C1081 XFE_E.NREGEN.n12 VSS 1.08892f
C1082 XFE_E.NREGEN.t5 VSS 0.32109f
C1083 XFE_E.NREGEN.t12 VSS 0.32406f
C1084 XFE_E.NREGEN.n13 VSS 1.09768f
C1085 XFE_E.NREGEN.n14 VSS 0.62125f
C1086 XFE_E.NREGEN.n15 VSS 1.92761f
C1087 XFE_E.NREGEN.t31 VSS 0.41272f
C1088 XFE_E.NREGEN.t32 VSS 0.40894f
C1089 XFE_E.NREGEN.n16 VSS 1.09768f
C1090 XFE_E.NREGEN.t29 VSS 1.5365f
C1091 XFE_E.NREGEN.n17 VSS 0.79737f
C1092 XFE_E.NREGEN.n18 VSS 2.26f
C1093 XFE_E.NREGEN.t25 VSS 1.49193f
C1094 XFE_E.NREGEN.t24 VSS 0.35183f
C1095 XFE_E.NREGEN.t23 VSS 0.35183f
C1096 XFE_E.NREGEN.n19 VSS 1.08892f
C1097 XFE_E.NREGEN.n20 VSS 0.55175f
C1098 XFE_E.NREGEN.t18 VSS 1.49193f
C1099 XFE_E.NREGEN.t20 VSS 0.35183f
C1100 XFE_E.NREGEN.t19 VSS 0.35183f
C1101 XFE_E.NREGEN.n21 VSS 1.08892f
C1102 XFE_E.NREGEN.n22 VSS 0.6137f
C1103 XFE_E.NREGEN.t22 VSS 0.35183f
C1104 XFE_E.NREGEN.t21 VSS 0.35183f
C1105 XFE_E.NREGEN.n23 VSS 1.08892f
C1106 XFE_E.NREGEN.n24 VSS 0.26092f
C1107 XFE_E.NREGEN.n25 VSS 0.19669f
C1108 XFE_E.NREGEN.n26 VSS 2.0413f
C1109 XFE_E.NREGEN.t3 VSS 0.41907f
C1110 XFE_E.NREGEN.t30 VSS 0.41517f
C1111 XFE_E.NREGEN.n27 VSS 1.09768f
C1112 XFE_E.NREGEN.t10 VSS 1.54273f
C1113 XFE_E.NREGEN.n28 VSS 0.79737f
C1114 XFE_E.NREGEN.n29 VSS 1.22864f
C1115 XFE_O.NREGEN.t19 VSS 1.4847f
C1116 XFE_O.NREGEN.t18 VSS 1.49452f
C1117 XFE_O.NREGEN.n0 VSS 1.51825f
C1118 XFE_O.NREGEN.t4 VSS 0.32406f
C1119 XFE_O.NREGEN.t15 VSS 0.32109f
C1120 XFE_O.NREGEN.n1 VSS 1.09768f
C1121 XFE_O.NREGEN.t7 VSS 0.32109f
C1122 XFE_O.NREGEN.t14 VSS 0.32109f
C1123 XFE_O.NREGEN.n2 VSS 1.08892f
C1124 XFE_O.NREGEN.t12 VSS 0.32109f
C1125 XFE_O.NREGEN.t13 VSS 0.32406f
C1126 XFE_O.NREGEN.n3 VSS 1.09768f
C1127 XFE_O.NREGEN.t1 VSS 0.32109f
C1128 XFE_O.NREGEN.t30 VSS 0.32109f
C1129 XFE_O.NREGEN.n4 VSS 1.08892f
C1130 XFE_O.NREGEN.n5 VSS 0.57192f
C1131 XFE_O.NREGEN.n6 VSS 0.62125f
C1132 XFE_O.NREGEN.n7 VSS 1.92761f
C1133 XFE_O.NREGEN.t33 VSS 0.40894f
C1134 XFE_O.NREGEN.t31 VSS 0.41272f
C1135 XFE_O.NREGEN.n8 VSS 1.09768f
C1136 XFE_O.NREGEN.t32 VSS 1.5365f
C1137 XFE_O.NREGEN.n9 VSS 0.79737f
C1138 XFE_O.NREGEN.n10 VSS 2.26f
C1139 XFE_O.NREGEN.t27 VSS 1.49193f
C1140 XFE_O.NREGEN.t26 VSS 0.35183f
C1141 XFE_O.NREGEN.t25 VSS 0.35183f
C1142 XFE_O.NREGEN.n11 VSS 1.08892f
C1143 XFE_O.NREGEN.n12 VSS 0.6137f
C1144 XFE_O.NREGEN.t24 VSS 0.35183f
C1145 XFE_O.NREGEN.t23 VSS 0.35183f
C1146 XFE_O.NREGEN.n13 VSS 1.08892f
C1147 XFE_O.NREGEN.n14 VSS 0.26092f
C1148 XFE_O.NREGEN.t20 VSS 1.49193f
C1149 XFE_O.NREGEN.t22 VSS 0.35183f
C1150 XFE_O.NREGEN.t21 VSS 0.35183f
C1151 XFE_O.NREGEN.n15 VSS 1.08892f
C1152 XFE_O.NREGEN.n16 VSS 0.55175f
C1153 XFE_O.NREGEN.n17 VSS 0.19669f
C1154 XFE_O.NREGEN.n18 VSS 2.0413f
C1155 XFE_O.NREGEN.t11 VSS 0.41517f
C1156 XFE_O.NREGEN.t5 VSS 0.41907f
C1157 XFE_O.NREGEN.n19 VSS 1.09768f
C1158 XFE_O.NREGEN.t10 VSS 1.54273f
C1159 XFE_O.NREGEN.n20 VSS 0.79737f
C1160 XFE_O.NREGEN.n21 VSS 1.23801f
C1161 XFE_O.NREGEN.t17 VSS 1.4847f
C1162 XFE_O.NREGEN.t16 VSS 1.49452f
C1163 XFE_O.NREGEN.n22 VSS 1.51825f
C1164 XFE_O.NREGEN.t8 VSS 0.31872f
C1165 XFE_O.NREGEN.t9 VSS 0.31589f
C1166 XFE_O.NREGEN.n23 VSS 1.09768f
C1167 XFE_O.NREGEN.t29 VSS 0.31589f
C1168 XFE_O.NREGEN.t3 VSS 0.31589f
C1169 XFE_O.NREGEN.n24 VSS 1.08892f
C1170 XFE_O.NREGEN.t6 VSS 0.31589f
C1171 XFE_O.NREGEN.t28 VSS 0.31872f
C1172 XFE_O.NREGEN.n25 VSS 1.09768f
C1173 XFE_O.NREGEN.t2 VSS 0.31589f
C1174 XFE_O.NREGEN.t0 VSS 0.31589f
C1175 XFE_O.NREGEN.n26 VSS 1.08892f
C1176 XFE_O.NREGEN.n27 VSS 0.57192f
C1177 XFE_O.NREGEN.n28 VSS 0.62125f
C1178 XFE_O.NREGEN.n29 VSS 1.81724f
C1179 XFE_O.NREGEN.n30 VSS 0.46869f
C1180 XFE_E.BN.t1 VSS 0.79219f
C1181 XFE_E.BN.t0 VSS 0.79713f
C1182 XFE_E.BN.n0 VSS 0.36943f
C1183 XFE_E.BN.t9 VSS 0.79583f
C1184 XFE_E.BN.t8 VSS 0.22254f
C1185 XFE_E.BN.t7 VSS 0.22254f
C1186 XFE_E.BN.n1 VSS 0.54671f
C1187 XFE_E.BN.n2 VSS 0.27702f
C1188 XFE_E.BN.t2 VSS 0.79583f
C1189 XFE_E.BN.t4 VSS 0.22254f
C1190 XFE_E.BN.t3 VSS 0.22254f
C1191 XFE_E.BN.n3 VSS 0.54671f
C1192 XFE_E.BN.n4 VSS 0.30812f
C1193 XFE_E.BN.t6 VSS 0.22254f
C1194 XFE_E.BN.t5 VSS 0.22254f
C1195 XFE_E.BN.n5 VSS 0.54671f
C1196 XFE_E.BN.n6 VSS 0.131f
C1197 XFE_E.BN.n7 VSS 0.15187f
C1198 XFE_E.BN.n8 VSS 0.54152f
C1199 XFE_E.BN.n9 VSS 0.05092f
C1200 XFE_E.BN.n10 VSS 0.17589f
C1201 XFE_E.BN.n11 VSS 0.08694f
C1202 XFE_E.BN.n12 VSS 0.09319f
C1203 XFE_E.BN.n13 VSS 0.09319f
C1204 XFE_E.BN.n14 VSS 0.09319f
C1205 XFE_E.BN.n15 VSS 0.08694f
C1206 XFE_E.BN.n16 VSS 0.17589f
C1207 XFE_E.BN.n17 VSS 0.09319f
C1208 XFE_E.BN.n18 VSS 0.09319f
C1209 XFE_E.BN.n19 VSS 0.09319f
C1210 XFE_E.BN.n20 VSS 0.05092f
C1211 XFE_E.BN.n21 VSS 0.04865f
C1212 XFE_E.BN.n22 VSS 0.06043f
C1213 XFE_E.BN.n23 VSS 0.06043f
C1214 XFE_E.BN.n24 VSS 0.17589f
C1215 XFE_E.BN.n25 VSS 0.08694f
C1216 XFE_E.BN.n26 VSS 0.09319f
C1217 XFE_E.BN.n27 VSS 0.09319f
C1218 XFE_E.BN.n28 VSS 0.09319f
C1219 XFE_E.BN.n29 VSS 0.09319f
C1220 XFE_E.BN.n30 VSS 0.08807f
C1221 XFE_E.BN.n31 VSS 0.27422f
C1222 XFE_E.BN.n32 VSS 0.6628f
C1223 XFE_E.SXN.t8 VSS 1.07869f
C1224 XFE_E.SXN.t11 VSS 0.33986f
C1225 XFE_E.SXN.t6 VSS 0.33986f
C1226 XFE_E.SXN.n0 VSS 0.70719f
C1227 XFE_E.SXN.n1 VSS 0.38872f
C1228 XFE_E.SXN.t3 VSS 0.33986f
C1229 XFE_E.SXN.t5 VSS 0.33986f
C1230 XFE_E.SXN.n2 VSS 0.70719f
C1231 XFE_E.SXN.n3 VSS 0.20292f
C1232 XFE_E.SXN.t1 VSS 0.33986f
C1233 XFE_E.SXN.t7 VSS 0.33986f
C1234 XFE_E.SXN.n4 VSS 0.70719f
C1235 XFE_E.SXN.n5 VSS 0.20292f
C1236 XFE_E.SXN.t2 VSS 1.06845f
C1237 XFE_E.SXN.n6 VSS 0.90335f
C1238 XFE_E.SXN.n7 VSS 0.42389f
C1239 XFE_E.SXN.n8 VSS 0.06537f
C1240 XFE_E.SXN.n9 VSS 0.22584f
C1241 XFE_E.SXN.n10 VSS 0.11163f
C1242 XFE_E.SXN.n11 VSS 0.11965f
C1243 XFE_E.SXN.n12 VSS 0.11965f
C1244 XFE_E.SXN.n13 VSS 0.11965f
C1245 XFE_E.SXN.n14 VSS 0.11163f
C1246 XFE_E.SXN.n15 VSS 0.22584f
C1247 XFE_E.SXN.n16 VSS 0.11965f
C1248 XFE_E.SXN.n17 VSS 0.11965f
C1249 XFE_E.SXN.n18 VSS 0.11965f
C1250 XFE_E.SXN.n19 VSS 0.06537f
C1251 XFE_E.SXN.n20 VSS 0.08065f
C1252 XFE_E.SXN.n21 VSS 1.52553f
C1253 XFE_E.SXN.t9 VSS 1.077f
C1254 XFE_E.SXN.t10 VSS 0.33986f
C1255 XFE_E.SXN.t4 VSS 0.33986f
C1256 XFE_E.SXN.n22 VSS 0.70198f
C1257 XFE_E.SXN.n23 VSS 0.39562f
C1258 XFE_E.SXN.t0 VSS 1.06675f
C1259 XFE_E.SXN.n24 VSS 0.93086f
C1260 XFE_E.SXN.n25 VSS 1.75356f
C1261 XFE_E.SXP.n0 VSS 0.44369f
C1262 XFE_E.SXP.n1 VSS 0.06633f
C1263 XFE_E.SXP.n2 VSS 0.22913f
C1264 XFE_E.SXP.n3 VSS 0.11325f
C1265 XFE_E.SXP.n4 VSS 0.1214f
C1266 XFE_E.SXP.n5 VSS 0.1214f
C1267 XFE_E.SXP.n6 VSS 0.1214f
C1268 XFE_E.SXP.n7 VSS 0.11325f
C1269 XFE_E.SXP.n8 VSS 0.22913f
C1270 XFE_E.SXP.n9 VSS 0.1214f
C1271 XFE_E.SXP.n10 VSS 0.1214f
C1272 XFE_E.SXP.n11 VSS 0.1214f
C1273 XFE_E.SXP.n12 VSS 0.06633f
C1274 XFE_E.SXP.n13 VSS 0.07275f
C1275 XFE_E.SXP.n14 VSS 0.88712f
C1276 XFE_E.SXP.t11 VSS 1.08502f
C1277 XFE_E.SXP.t9 VSS 0.33562f
C1278 XFE_E.SXP.t10 VSS 0.33562f
C1279 XFE_E.SXP.n15 VSS 0.71748f
C1280 XFE_E.SXP.n16 VSS 0.39438f
C1281 XFE_E.SXP.t7 VSS 0.33562f
C1282 XFE_E.SXP.t8 VSS 0.33562f
C1283 XFE_E.SXP.n17 VSS 0.71748f
C1284 XFE_E.SXP.n18 VSS 0.20587f
C1285 XFE_E.SXP.t5 VSS 0.33562f
C1286 XFE_E.SXP.t6 VSS 0.33562f
C1287 XFE_E.SXP.n19 VSS 0.71748f
C1288 XFE_E.SXP.n20 VSS 0.20587f
C1289 XFE_E.SXP.t4 VSS 1.07481f
C1290 XFE_E.SXP.n21 VSS 0.5855f
C1291 XFE_E.SXP.t3 VSS 1.08331f
C1292 XFE_E.SXP.t1 VSS 0.33562f
C1293 XFE_E.SXP.t2 VSS 0.33562f
C1294 XFE_E.SXP.n22 VSS 0.71219f
C1295 XFE_E.SXP.n23 VSS 0.40138f
C1296 XFE_E.SXP.t0 VSS 1.07309f
C1297 XFE_E.SXP.n24 VSS 0.57887f
C1298 XFE_E.SXP.n25 VSS 1.39041f
C1299 XFE_E.BP.n0 VSS 0.04911f
C1300 XFE_E.BP.n1 VSS 0.16966f
C1301 XFE_E.BP.n2 VSS 0.08386f
C1302 XFE_E.BP.n3 VSS 0.08989f
C1303 XFE_E.BP.n4 VSS 0.08989f
C1304 XFE_E.BP.n5 VSS 0.08989f
C1305 XFE_E.BP.n6 VSS 0.08386f
C1306 XFE_E.BP.n7 VSS 0.16966f
C1307 XFE_E.BP.n8 VSS 0.08989f
C1308 XFE_E.BP.n9 VSS 0.08989f
C1309 XFE_E.BP.n10 VSS 0.08989f
C1310 XFE_E.BP.n11 VSS 0.04911f
C1311 XFE_E.BP.n12 VSS 0.05215f
C1312 XFE_E.BP.n13 VSS 0.05829f
C1313 XFE_E.BP.n14 VSS 0.08989f
C1314 XFE_E.BP.n15 VSS 0.08989f
C1315 XFE_E.BP.n16 VSS 0.08386f
C1316 XFE_E.BP.n17 VSS 0.16966f
C1317 XFE_E.BP.n18 VSS 0.05829f
C1318 XFE_E.BP.n19 VSS 0.08989f
C1319 XFE_E.BP.n20 VSS 0.08989f
C1320 XFE_E.BP.n21 VSS 0.08495f
C1321 XFE_E.BP.n22 VSS 0.25147f
C1322 XFE_E.BP.n23 VSS 0.57807f
C1323 XFE_E.BP.t9 VSS 0.77005f
C1324 XFE_E.BP.t3 VSS 0.77482f
C1325 XFE_E.BP.n24 VSS 0.37042f
C1326 XFE_E.BP.t0 VSS 0.77356f
C1327 XFE_E.BP.t1 VSS 0.22046f
C1328 XFE_E.BP.t2 VSS 0.22046f
C1329 XFE_E.BP.n25 VSS 0.52735f
C1330 XFE_E.BP.n26 VSS 0.26721f
C1331 XFE_E.BP.t8 VSS 0.77356f
C1332 XFE_E.BP.t6 VSS 0.22046f
C1333 XFE_E.BP.t7 VSS 0.22046f
C1334 XFE_E.BP.n27 VSS 0.52735f
C1335 XFE_E.BP.n28 VSS 0.29721f
C1336 XFE_E.BP.t4 VSS 0.22046f
C1337 XFE_E.BP.t5 VSS 0.22046f
C1338 XFE_E.BP.n29 VSS 0.52735f
C1339 XFE_E.BP.n30 VSS 0.12636f
C1340 XFE_E.BP.n31 VSS 0.13242f
C1341 XFE_E.BP.n32 VSS 0.57347f
C1342 XFE_O.BP.t1 VSS 0.77482f
C1343 XFE_O.BP.t0 VSS 0.77005f
C1344 XFE_O.BP.n0 VSS 0.37042f
C1345 XFE_O.BP.t9 VSS 0.77356f
C1346 XFE_O.BP.t8 VSS 0.22046f
C1347 XFE_O.BP.t7 VSS 0.22046f
C1348 XFE_O.BP.n1 VSS 0.52735f
C1349 XFE_O.BP.n2 VSS 0.29721f
C1350 XFE_O.BP.t6 VSS 0.22046f
C1351 XFE_O.BP.t5 VSS 0.22046f
C1352 XFE_O.BP.n3 VSS 0.52735f
C1353 XFE_O.BP.n4 VSS 0.12636f
C1354 XFE_O.BP.t2 VSS 0.77356f
C1355 XFE_O.BP.t4 VSS 0.22046f
C1356 XFE_O.BP.t3 VSS 0.22046f
C1357 XFE_O.BP.n5 VSS 0.52735f
C1358 XFE_O.BP.n6 VSS 0.26721f
C1359 XFE_O.BP.n7 VSS 0.13242f
C1360 XFE_O.BP.n8 VSS 0.57561f
C1361 XFE_O.BP.n9 VSS 0.04911f
C1362 XFE_O.BP.n10 VSS 0.16966f
C1363 XFE_O.BP.n11 VSS 0.08386f
C1364 XFE_O.BP.n12 VSS 0.08989f
C1365 XFE_O.BP.n13 VSS 0.08989f
C1366 XFE_O.BP.n14 VSS 0.08989f
C1367 XFE_O.BP.n15 VSS 0.08386f
C1368 XFE_O.BP.n16 VSS 0.16966f
C1369 XFE_O.BP.n17 VSS 0.08989f
C1370 XFE_O.BP.n18 VSS 0.08989f
C1371 XFE_O.BP.n19 VSS 0.08989f
C1372 XFE_O.BP.n20 VSS 0.04911f
C1373 XFE_O.BP.n21 VSS 0.05215f
C1374 XFE_O.BP.n22 VSS 0.05829f
C1375 XFE_O.BP.n23 VSS 0.05829f
C1376 XFE_O.BP.n24 VSS 0.16966f
C1377 XFE_O.BP.n25 VSS 0.08386f
C1378 XFE_O.BP.n26 VSS 0.08989f
C1379 XFE_O.BP.n27 VSS 0.08989f
C1380 XFE_O.BP.n28 VSS 0.08989f
C1381 XFE_O.BP.n29 VSS 0.08989f
C1382 XFE_O.BP.n30 VSS 0.08495f
C1383 XFE_O.BP.n31 VSS 0.25147f
C1384 XFE_O.BP.n32 VSS 0.57788f
C1385 XFE_O.BP.n33 VSS 0.34059f
C1386 XFE_O.SXP.t11 VSS 1.08502f
C1387 XFE_O.SXP.t8 VSS 0.33562f
C1388 XFE_O.SXP.t9 VSS 0.33562f
C1389 XFE_O.SXP.n0 VSS 0.71748f
C1390 XFE_O.SXP.n1 VSS 0.39438f
C1391 XFE_O.SXP.t3 VSS 0.33562f
C1392 XFE_O.SXP.t4 VSS 0.33562f
C1393 XFE_O.SXP.n2 VSS 0.71748f
C1394 XFE_O.SXP.n3 VSS 0.20587f
C1395 XFE_O.SXP.t1 VSS 0.33562f
C1396 XFE_O.SXP.t2 VSS 0.33562f
C1397 XFE_O.SXP.n4 VSS 0.71748f
C1398 XFE_O.SXP.n5 VSS 0.20587f
C1399 XFE_O.SXP.t0 VSS 1.07481f
C1400 XFE_O.SXP.n6 VSS 0.5855f
C1401 XFE_O.SXP.t7 VSS 1.08331f
C1402 XFE_O.SXP.t5 VSS 0.33562f
C1403 XFE_O.SXP.t6 VSS 0.33562f
C1404 XFE_O.SXP.n7 VSS 0.71219f
C1405 XFE_O.SXP.n8 VSS 0.40138f
C1406 XFE_O.SXP.t10 VSS 1.07309f
C1407 XFE_O.SXP.n9 VSS 0.57887f
C1408 XFE_O.SXP.n10 VSS 1.39499f
C1409 XFE_O.SXP.n11 VSS 0.44369f
C1410 XFE_O.SXP.n12 VSS 0.06633f
C1411 XFE_O.SXP.n13 VSS 0.22913f
C1412 XFE_O.SXP.n14 VSS 0.11325f
C1413 XFE_O.SXP.n15 VSS 0.1214f
C1414 XFE_O.SXP.n16 VSS 0.1214f
C1415 XFE_O.SXP.n17 VSS 0.1214f
C1416 XFE_O.SXP.n18 VSS 0.11325f
C1417 XFE_O.SXP.n19 VSS 0.22913f
C1418 XFE_O.SXP.n20 VSS 0.1214f
C1419 XFE_O.SXP.n21 VSS 0.1214f
C1420 XFE_O.SXP.n22 VSS 0.1214f
C1421 XFE_O.SXP.n23 VSS 0.06633f
C1422 XFE_O.SXP.n24 VSS 0.07275f
C1423 XFE_O.SXP.n25 VSS 0.88687f
C1424 XFE_O.SXP.n26 VSS 1.78078f
C1425 XFE_O.SXN.n0 VSS 0.42389f
C1426 XFE_O.SXN.n1 VSS 0.06537f
C1427 XFE_O.SXN.n2 VSS 0.22584f
C1428 XFE_O.SXN.n3 VSS 0.11163f
C1429 XFE_O.SXN.n4 VSS 0.11965f
C1430 XFE_O.SXN.n5 VSS 0.11965f
C1431 XFE_O.SXN.n6 VSS 0.11965f
C1432 XFE_O.SXN.n7 VSS 0.11163f
C1433 XFE_O.SXN.n8 VSS 0.22584f
C1434 XFE_O.SXN.n9 VSS 0.11965f
C1435 XFE_O.SXN.n10 VSS 0.11965f
C1436 XFE_O.SXN.n11 VSS 0.11965f
C1437 XFE_O.SXN.n12 VSS 0.06537f
C1438 XFE_O.SXN.n13 VSS 0.08065f
C1439 XFE_O.SXN.n14 VSS 1.52553f
C1440 XFE_O.SXN.t9 VSS 1.077f
C1441 XFE_O.SXN.t0 VSS 0.33986f
C1442 XFE_O.SXN.t1 VSS 0.33986f
C1443 XFE_O.SXN.n15 VSS 0.70198f
C1444 XFE_O.SXN.n16 VSS 0.39562f
C1445 XFE_O.SXN.t2 VSS 1.06675f
C1446 XFE_O.SXN.n17 VSS 0.93086f
C1447 XFE_O.SXN.n18 VSS 1.75961f
C1448 XFE_O.SXN.t11 VSS 1.07869f
C1449 XFE_O.SXN.t7 VSS 0.33986f
C1450 XFE_O.SXN.t8 VSS 0.33986f
C1451 XFE_O.SXN.n19 VSS 0.70719f
C1452 XFE_O.SXN.n20 VSS 0.38872f
C1453 XFE_O.SXN.t3 VSS 0.33986f
C1454 XFE_O.SXN.t4 VSS 0.33986f
C1455 XFE_O.SXN.n21 VSS 0.70719f
C1456 XFE_O.SXN.n22 VSS 0.20292f
C1457 XFE_O.SXN.t5 VSS 0.33986f
C1458 XFE_O.SXN.t6 VSS 0.33986f
C1459 XFE_O.SXN.n23 VSS 0.70719f
C1460 XFE_O.SXN.n24 VSS 0.20292f
C1461 XFE_O.SXN.t10 VSS 1.06845f
C1462 XFE_O.SXN.n25 VSS 0.90216f
C1463 XFE_O.SXN.n26 VSS 0.5459f
C1464 XFE_O.BN.n0 VSS 0.05092f
C1465 XFE_O.BN.n1 VSS 0.17589f
C1466 XFE_O.BN.n2 VSS 0.08694f
C1467 XFE_O.BN.n3 VSS 0.09319f
C1468 XFE_O.BN.n4 VSS 0.09319f
C1469 XFE_O.BN.n5 VSS 0.09319f
C1470 XFE_O.BN.n6 VSS 0.08694f
C1471 XFE_O.BN.n7 VSS 0.17589f
C1472 XFE_O.BN.n8 VSS 0.09319f
C1473 XFE_O.BN.n9 VSS 0.09319f
C1474 XFE_O.BN.n10 VSS 0.09319f
C1475 XFE_O.BN.n11 VSS 0.05092f
C1476 XFE_O.BN.n12 VSS 0.04865f
C1477 XFE_O.BN.n13 VSS 0.06043f
C1478 XFE_O.BN.n14 VSS 0.09319f
C1479 XFE_O.BN.n15 VSS 0.09319f
C1480 XFE_O.BN.n16 VSS 0.08694f
C1481 XFE_O.BN.n17 VSS 0.17589f
C1482 XFE_O.BN.n18 VSS 0.06043f
C1483 XFE_O.BN.n19 VSS 0.09319f
C1484 XFE_O.BN.n20 VSS 0.09319f
C1485 XFE_O.BN.n21 VSS 0.08807f
C1486 XFE_O.BN.n22 VSS 0.27422f
C1487 XFE_O.BN.n23 VSS 0.66526f
C1488 XFE_O.BN.t1 VSS 0.79713f
C1489 XFE_O.BN.t2 VSS 0.79219f
C1490 XFE_O.BN.n24 VSS 0.36943f
C1491 XFE_O.BN.t9 VSS 0.79583f
C1492 XFE_O.BN.t3 VSS 0.22254f
C1493 XFE_O.BN.t4 VSS 0.22254f
C1494 XFE_O.BN.n25 VSS 0.54671f
C1495 XFE_O.BN.n26 VSS 0.30812f
C1496 XFE_O.BN.t5 VSS 0.22254f
C1497 XFE_O.BN.t6 VSS 0.22254f
C1498 XFE_O.BN.n27 VSS 0.54671f
C1499 XFE_O.BN.n28 VSS 0.131f
C1500 XFE_O.BN.t0 VSS 0.79583f
C1501 XFE_O.BN.t7 VSS 0.22254f
C1502 XFE_O.BN.t8 VSS 0.22254f
C1503 XFE_O.BN.n29 VSS 0.54671f
C1504 XFE_O.BN.n30 VSS 0.27702f
C1505 XFE_O.BN.n31 VSS 0.15187f
C1506 XFE_O.BN.n32 VSS 0.54133f
C1507 XFE_O.BN.n33 VSS 0.40957f
C1508 XFE_E.NTAIL.t8 VSS 0.17332f
C1509 XFE_E.NTAIL.t9 VSS 0.17332f
C1510 XFE_E.NTAIL.n0 VSS 0.91027f
C1511 XFE_E.NTAIL.t6 VSS 0.19081f
C1512 XFE_E.NTAIL.t7 VSS 0.19081f
C1513 XFE_E.NTAIL.n1 VSS 0.97526f
C1514 XFE_E.NTAIL.t11 VSS 0.92647f
C1515 XFE_E.NTAIL.t10 VSS 0.93208f
C1516 XFE_E.NTAIL.n2 VSS 0.44321f
C1517 XFE_E.NTAIL.n3 VSS 1.31879f
C1518 XFE_E.NTAIL.t5 VSS 0.84943f
C1519 XFE_E.NTAIL.t0 VSS 0.85119f
C1520 XFE_E.NTAIL.t2 VSS 0.20358f
C1521 XFE_E.NTAIL.t1 VSS 0.20358f
C1522 XFE_E.NTAIL.n4 VSS 0.61999f
C1523 XFE_E.NTAIL.n5 VSS 0.34942f
C1524 XFE_E.NTAIL.t4 VSS 0.20358f
C1525 XFE_E.NTAIL.t3 VSS 0.20358f
C1526 XFE_E.NTAIL.n6 VSS 0.61999f
C1527 XFE_E.NTAIL.n7 VSS 0.14856f
C1528 XFE_E.NTAIL.n8 VSS 0.31063f
C1529 XFE_E.NTAIL.n9 VSS 0.61878f
C1530 XFE_O.NTAIL.t2 VSS 0.19075f
C1531 XFE_O.NTAIL.t3 VSS 0.19075f
C1532 XFE_O.NTAIL.n0 VSS 0.97526f
C1533 XFE_O.NTAIL.t5 VSS 0.93208f
C1534 XFE_O.NTAIL.t4 VSS 0.92647f
C1535 XFE_O.NTAIL.n1 VSS 0.44321f
C1536 XFE_O.NTAIL.n2 VSS 1.31879f
C1537 XFE_O.NTAIL.t11 VSS 0.85119f
C1538 XFE_O.NTAIL.t10 VSS 0.20358f
C1539 XFE_O.NTAIL.t9 VSS 0.20358f
C1540 XFE_O.NTAIL.n3 VSS 0.61999f
C1541 XFE_O.NTAIL.n4 VSS 0.34942f
C1542 XFE_O.NTAIL.t8 VSS 0.20358f
C1543 XFE_O.NTAIL.t7 VSS 0.20358f
C1544 XFE_O.NTAIL.n5 VSS 0.61999f
C1545 XFE_O.NTAIL.n6 VSS 0.14856f
C1546 XFE_O.NTAIL.t6 VSS 0.84943f
C1547 XFE_O.NTAIL.n7 VSS 0.31063f
C1548 XFE_O.NTAIL.n8 VSS 0.62412f
C1549 XFE_O.NTAIL.t0 VSS 0.17348f
C1550 XFE_O.NTAIL.t1 VSS 0.17348f
C1551 XFE_O.NTAIL.n9 VSS 0.90948f
C1552 XFE_O.NTAIL.n10 VSS 0.53201f
C1553 a_948_44200.t5 VSS 0.63799f
C1554 a_948_44200.t1 VSS 0.1331f
C1555 a_948_44200.t0 VSS 0.1331f
C1556 a_948_44200.n0 VSS 0.51748f
C1557 a_948_44200.t3 VSS 0.13204f
C1558 a_948_44200.t2 VSS 0.13204f
C1559 a_948_44200.n1 VSS 0.47973f
C1560 a_948_44200.n2 VSS 3.66241f
C1561 a_948_44200.n3 VSS 0.50661f
C1562 a_948_44200.t4 VSS 0.63799f
C1563 a_2548_44200.t5 VSS 0.84552f
C1564 a_2548_44200.t3 VSS 0.16249f
C1565 a_2548_44200.t2 VSS 0.16249f
C1566 a_2548_44200.n0 VSS 0.62947f
C1567 a_2548_44200.t1 VSS 0.17593f
C1568 a_2548_44200.t0 VSS 0.17593f
C1569 a_2548_44200.n1 VSS 0.59103f
C1570 a_2548_44200.n2 VSS 2.81846f
C1571 a_2548_44200.n3 VSS 0.69295f
C1572 a_2548_44200.t4 VSS 0.84552f
C1573 a_10548_44200.t0 VSS 0.61673f
C1574 a_10548_44200.t3 VSS 0.13032f
C1575 a_10548_44200.t2 VSS 0.13032f
C1576 a_10548_44200.n0 VSS 0.50161f
C1577 a_10548_44200.t5 VSS 0.12927f
C1578 a_10548_44200.t4 VSS 0.12927f
C1579 a_10548_44200.n1 VSS 0.46501f
C1580 a_10548_44200.n2 VSS 3.55006f
C1581 a_10548_44200.n3 VSS 0.49107f
C1582 a_10548_44200.t1 VSS 0.61673f
C1583 a_12148_44200.t5 VSS 0.83953f
C1584 a_12148_44200.t3 VSS 0.17456f
C1585 a_12148_44200.t2 VSS 0.17456f
C1586 a_12148_44200.n0 VSS 0.62265f
C1587 a_12148_44200.t1 VSS 0.16129f
C1588 a_12148_44200.t0 VSS 0.16129f
C1589 a_12148_44200.n1 VSS 0.58462f
C1590 a_12148_44200.n2 VSS 2.78788f
C1591 a_12148_44200.n3 VSS 0.68544f
C1592 a_12148_44200.t4 VSS 0.83953f
C1593 a_2148_41600.t5 VSS 0.1448f
C1594 a_2148_41600.t7 VSS 0.59332f
C1595 a_2148_41600.n0 VSS 0.11907f
C1596 a_2148_41600.t1 VSS 0.1243f
C1597 a_2148_41600.t0 VSS 0.1243f
C1598 a_2148_41600.n1 VSS 0.38577f
C1599 a_2148_41600.t3 VSS 0.12712f
C1600 a_2148_41600.t2 VSS 0.12712f
C1601 a_2148_41600.n2 VSS 0.38577f
C1602 a_2148_41600.n3 VSS 1.18313f
C1603 a_2148_41600.n4 VSS 0.35665f
C1604 a_2148_41600.t4 VSS 0.59158f
C1605 a_2148_41600.n5 VSS 0.12082f
C1606 a_2148_41600.n6 VSS 0.13505f
C1607 a_2148_41600.n7 VSS 0.41454f
C1608 a_2148_41600.t6 VSS 0.1448f
C1609 a_11748_41600.t5 VSS 0.14207f
C1610 a_11748_41600.t7 VSS 0.57975f
C1611 a_11748_41600.n0 VSS 0.11619f
C1612 a_11748_41600.t3 VSS 0.12494f
C1613 a_11748_41600.t2 VSS 0.12494f
C1614 a_11748_41600.n1 VSS 0.37643f
C1615 a_11748_41600.t1 VSS 0.12212f
C1616 a_11748_41600.t0 VSS 0.12212f
C1617 a_11748_41600.n2 VSS 0.37643f
C1618 a_11748_41600.n3 VSS 1.15448f
C1619 a_11748_41600.n4 VSS 0.34802f
C1620 a_11748_41600.t4 VSS 0.57804f
C1621 a_11748_41600.n5 VSS 0.1179f
C1622 a_11748_41600.n6 VSS 0.13178f
C1623 a_11748_41600.n7 VSS 0.40451f
C1624 a_11748_41600.t6 VSS 0.14207f
C1625 a_n1000_22678.t1 VSS 0.43066f
C1626 a_n1000_22678.t0 VSS 0.11274f
C1627 a_n1000_22678.n0 VSS 0.61981f
C1628 a_n1000_22678.n1 VSS 1.98011f
C1629 a_n1000_22678.n2 VSS 0.20692f
C1630 a_n1000_22678.t2 VSS 0.43066f
C1631 a_600_22678.t1 VSS 0.47347f
C1632 a_600_22678.t0 VSS 0.12618f
C1633 a_600_22678.n0 VSS 0.69373f
C1634 a_600_22678.n1 VSS 2.21625f
C1635 a_600_22678.n2 VSS 0.23159f
C1636 a_600_22678.t2 VSS 0.47347f
C1637 a_n852_28800.t2 VSS 0.17014f
C1638 a_n852_28800.t1 VSS 0.17014f
C1639 a_n852_28800.n0 VSS 0.49564f
C1640 a_n852_28800.n1 VSS 0.14146f
C1641 a_n852_28800.t0 VSS 0.70725f
C1642 a_n852_28800.n2 VSS 0.12671f
C1643 a_n852_28800.t4 VSS 0.18675f
C1644 a_n852_28800.t6 VSS 0.18675f
C1645 a_n852_28800.n3 VSS 0.46111f
C1646 a_n852_28800.t7 VSS 0.17892f
C1647 a_n852_28800.t5 VSS 0.17892f
C1648 a_n852_28800.n4 VSS 0.46111f
C1649 a_n852_28800.n5 VSS 0.96575f
C1650 a_n852_28800.n6 VSS 0.42664f
C1651 a_n852_28800.n7 VSS 0.12494f
C1652 a_n852_28800.t3 VSS 0.70902f
C1653 a_n852_19400.t4 VSS 0.18447f
C1654 a_n852_19400.t3 VSS 0.18447f
C1655 a_n852_19400.n0 VSS 0.5479f
C1656 a_n852_19400.n1 VSS 0.15638f
C1657 a_n852_19400.t2 VSS 0.77818f
C1658 a_n852_19400.n2 VSS 0.14008f
C1659 a_n852_19400.t7 VSS 0.16971f
C1660 a_n852_19400.t6 VSS 0.16971f
C1661 a_n852_19400.n3 VSS 0.50974f
C1662 a_n852_19400.t1 VSS 0.17261f
C1663 a_n852_19400.t0 VSS 0.17261f
C1664 a_n852_19400.n4 VSS 0.50974f
C1665 a_n852_19400.n5 VSS 1.06759f
C1666 a_n852_19400.n6 VSS 0.47163f
C1667 a_n852_19400.n7 VSS 0.13812f
C1668 a_n852_19400.t5 VSS 0.78013f
C1669 a_n6716_3500.t0 VSS 0.543f
C1670 a_n6716_3500.t1 VSS 1.11245f
C1671 a_n6572_3500.t3 VSS 0.53009f
C1672 a_n6572_3500.t0 VSS 0.11763f
C1673 a_n6572_3500.t1 VSS 0.11768f
C1674 a_n6572_3500.n0 VSS 0.18549f
C1675 a_n6572_3500.t5 VSS 0.36985f
C1676 a_n6572_3500.t2 VSS 0.15622f
C1677 a_n6572_3500.n1 VSS 1.39633f
C1678 a_n6572_3500.n2 VSS 0.64607f
C1679 a_n6572_3500.n3 VSS 0.84861f
C1680 a_n6572_3500.n4 VSS 2.74162f
C1681 a_n6572_3500.n5 VSS 0.25248f
C1682 a_n6572_3500.t4 VSS 0.53018f
C1683 a_n3600_5641.t0 VSS 0.49714f
C1684 a_n3600_5641.t2 VSS 0.11508f
C1685 a_n3600_5641.t3 VSS 0.11503f
C1686 a_n3600_5641.n0 VSS 0.18273f
C1687 a_n3600_5641.t4 VSS 0.3653f
C1688 a_n3600_5641.t5 VSS 0.1539f
C1689 a_n3600_5641.n1 VSS 1.37555f
C1690 a_n3600_5641.n2 VSS 0.55474f
C1691 a_n3600_5641.n3 VSS 1.07214f
C1692 a_n3600_5641.n4 VSS 2.44613f
C1693 a_n3600_5641.n5 VSS 0.28121f
C1694 a_n3600_5641.t1 VSS 0.49705f
C1695 a_n1900_5958.t0 VSS 0.5683f
C1696 a_n1900_5958.t1 VSS 1.16128f
C1697 a_484_3500.t0 VSS 0.57067f
C1698 a_484_3500.t1 VSS 1.16586f
C1699 a_5300_5958.t0 VSS 0.53942f
C1700 a_5300_5958.t1 VSS 1.11788f
C1701 a_n5052_2600.t5 VSS 0.03011f
C1702 a_n5052_2600.t7 VSS 0.12119f
C1703 a_n5052_2600.t4 VSS 0.12119f
C1704 a_n5052_2600.t3 VSS 0.04306f
C1705 a_n5052_2600.t2 VSS 0.04303f
C1706 a_n5052_2600.n0 VSS 0.10737f
C1707 a_n5052_2600.t1 VSS 0.04419f
C1708 a_n5052_2600.t0 VSS 0.04422f
C1709 a_n5052_2600.n1 VSS 0.10737f
C1710 a_n5052_2600.n2 VSS 0.98516f
C1711 a_n5052_2600.n3 VSS 0.46257f
C1712 a_n5052_2600.n4 VSS 0.09122f
C1713 a_n5052_2600.t6 VSS 0.03011f
C1714 a_n5052_n1000.t5 VSS 0.15561f
C1715 a_n5052_n1000.t4 VSS 0.15561f
C1716 a_n5052_n1000.t3 VSS 0.15561f
C1717 a_n5052_n1000.n0 VSS 0.45893f
C1718 a_n5052_n1000.n1 VSS 0.14951f
C1719 a_n5052_n1000.t2 VSS 0.65016f
C1720 a_n5052_n1000.n2 VSS 0.13501f
C1721 a_n5052_n1000.t0 VSS 0.14185f
C1722 a_n5052_n1000.t1 VSS 0.14185f
C1723 a_n5052_n1000.n3 VSS 0.50742f
C1724 a_n5052_n1000.t7 VSS 0.16764f
C1725 a_n5052_n1000.t8 VSS 0.16764f
C1726 a_n5052_n1000.n4 VSS 0.50742f
C1727 a_n5052_n1000.n5 VSS 1.21852f
C1728 a_n5052_n1000.n6 VSS 0.49183f
C1729 a_n5052_n1000.n7 VSS 0.11815f
C1730 a_n5052_n1000.n8 VSS 0.4607f
C1731 a_n5052_n1000.t6 VSS 0.15606f
C1732 a_2148_n500.t3 VSS 0.10871f
C1733 a_2148_n500.t2 VSS 0.10871f
C1734 a_2148_n500.t1 VSS 0.10871f
C1735 a_2148_n500.n0 VSS 0.28658f
C1736 a_2148_n500.n1 VSS 0.09336f
C1737 a_2148_n500.t0 VSS 0.4177f
C1738 a_2148_n500.n2 VSS 0.08431f
C1739 a_2148_n500.t5 VSS 0.08272f
C1740 a_2148_n500.t7 VSS 0.08272f
C1741 a_2148_n500.n3 VSS 0.17591f
C1742 a_2148_n500.t6 VSS 0.08338f
C1743 a_2148_n500.t8 VSS 0.08338f
C1744 a_2148_n500.n4 VSS 0.17591f
C1745 a_2148_n500.n5 VSS 0.81634f
C1746 a_2148_n500.n6 VSS 0.37461f
C1747 a_2148_n500.n7 VSS 0.07378f
C1748 a_2148_n500.n8 VSS 0.28768f
C1749 a_2148_n500.t4 VSS 0.10916f
C1750 a_n10800_n12572.n0 VSS 0.74217f
C1751 a_n10800_n12572.t1 VSS 0.12063f
C1752 a_n10800_n12572.n1 VSS 1.77193f
C1753 a_n10800_n12572.t0 VSS 0.16741f
C1754 a_n7300_n12700.t0 VSS 1.02298f
C1755 a_n7300_n12700.t3 VSS 0.97775f
C1756 a_n7300_n12700.t4 VSS 0.97215f
C1757 a_n7300_n12700.n0 VSS 0.54148f
C1758 a_n7300_n12700.t2 VSS 0.1493f
C1759 a_n7300_n12700.n1 VSS 2.1793f
C1760 a_n7300_n12700.n2 VSS 0.35701f
C1761 a_n7300_n12700.t1 VSS 1.01737f
C1762 a_n6400_n12652.t1 VSS 0.31174f
C1763 a_n6400_n12652.t3 VSS 0.26683f
C1764 a_n6400_n12652.t4 VSS 0.26683f
C1765 a_n6400_n12652.n0 VSS 0.82091f
C1766 a_n6400_n12652.t2 VSS 0.16832f
C1767 a_n6400_n12652.n1 VSS 2.87005f
C1768 a_n6400_n12652.n2 VSS 0.94209f
C1769 a_n6400_n12652.t0 VSS 0.31174f
C1770 a_n10800_n14372.n0 VSS 0.8249f
C1771 a_n10800_n14372.t1 VSS 0.12987f
C1772 a_n10800_n14372.n1 VSS 1.96946f
C1773 a_n10800_n14372.t0 VSS 0.18155f
C1774 a_n7300_n14500.t1 VSS 1.05346f
C1775 a_n7300_n14500.t4 VSS 1.01146f
C1776 a_n7300_n14500.t3 VSS 1.0057f
C1777 a_n7300_n14500.n0 VSS 0.55746f
C1778 a_n7300_n14500.t0 VSS 0.15371f
C1779 a_n7300_n14500.n1 VSS 2.24362f
C1780 a_n7300_n14500.n2 VSS 0.36754f
C1781 a_n7300_n14500.t2 VSS 1.04768f
C1782 a_n6400_n14452.t1 VSS 0.31383f
C1783 a_n6400_n14452.t4 VSS 0.27216f
C1784 a_n6400_n14452.t3 VSS 0.27216f
C1785 a_n6400_n14452.n0 VSS 0.81591f
C1786 a_n6400_n14452.t2 VSS 0.16729f
C1787 a_n6400_n14452.n1 VSS 2.85257f
C1788 a_n6400_n14452.n2 VSS 0.93635f
C1789 a_n6400_n14452.t0 VSS 0.31383f
C1790 a_n10800_n16172.n0 VSS 0.8249f
C1791 a_n10800_n16172.t1 VSS 0.12987f
C1792 a_n10800_n16172.n1 VSS 1.96946f
C1793 a_n10800_n16172.t0 VSS 0.18155f
C1794 a_n7300_n16300.t2 VSS 1.05346f
C1795 a_n7300_n16300.t4 VSS 1.01146f
C1796 a_n7300_n16300.t1 VSS 1.0057f
C1797 a_n7300_n16300.n0 VSS 0.55746f
C1798 a_n7300_n16300.t0 VSS 0.15371f
C1799 a_n7300_n16300.n1 VSS 2.24362f
C1800 a_n7300_n16300.n2 VSS 0.36754f
C1801 a_n7300_n16300.t3 VSS 1.04768f
C1802 a_n6400_n16252.t4 VSS 0.27216f
C1803 a_n6400_n16252.t0 VSS 0.16729f
C1804 a_n6400_n16252.t2 VSS 0.31383f
C1805 a_n6400_n16252.t3 VSS 0.31383f
C1806 a_n6400_n16252.n0 VSS 0.93635f
C1807 a_n6400_n16252.n1 VSS 2.85257f
C1808 a_n6400_n16252.n2 VSS 0.81591f
C1809 a_n6400_n16252.t1 VSS 0.27216f
C1810 a_n10800_n17972.n0 VSS 0.8249f
C1811 a_n10800_n17972.t1 VSS 0.12987f
C1812 a_n10800_n17972.n1 VSS 1.96946f
C1813 a_n10800_n17972.t0 VSS 0.18155f
C1814 a_n7300_n18100.t0 VSS 1.05346f
C1815 a_n7300_n18100.t2 VSS 1.01146f
C1816 a_n7300_n18100.t4 VSS 1.0057f
C1817 a_n7300_n18100.n0 VSS 0.55746f
C1818 a_n7300_n18100.t3 VSS 0.15371f
C1819 a_n7300_n18100.n1 VSS 2.24362f
C1820 a_n7300_n18100.n2 VSS 0.36754f
C1821 a_n7300_n18100.t1 VSS 1.04768f
C1822 a_n6400_n18052.t1 VSS 0.31383f
C1823 a_n6400_n18052.t3 VSS 0.27216f
C1824 a_n6400_n18052.t4 VSS 0.27216f
C1825 a_n6400_n18052.n0 VSS 0.81591f
C1826 a_n6400_n18052.t2 VSS 0.16729f
C1827 a_n6400_n18052.n1 VSS 2.85257f
C1828 a_n6400_n18052.n2 VSS 0.93635f
C1829 a_n6400_n18052.t0 VSS 0.31383f
C1830 a_n10800_n19772.n0 VSS 0.8249f
C1831 a_n10800_n19772.t1 VSS 0.12987f
C1832 a_n10800_n19772.n1 VSS 1.96946f
C1833 a_n10800_n19772.t0 VSS 0.18155f
C1834 a_n7300_n19900.t2 VSS 1.05359f
C1835 a_n7300_n19900.t4 VSS 1.01158f
C1836 a_n7300_n19900.t0 VSS 1.00582f
C1837 a_n7300_n19900.n0 VSS 0.55754f
C1838 a_n7300_n19900.t1 VSS 0.15373f
C1839 a_n7300_n19900.n1 VSS 2.24392f
C1840 a_n7300_n19900.n2 VSS 0.36759f
C1841 a_n7300_n19900.t3 VSS 1.0478f
C1842 a_n6400_n19852.t4 VSS 0.27216f
C1843 a_n6400_n19852.t0 VSS 0.16729f
C1844 a_n6400_n19852.t2 VSS 0.31383f
C1845 a_n6400_n19852.t3 VSS 0.31383f
C1846 a_n6400_n19852.n0 VSS 0.93635f
C1847 a_n6400_n19852.n1 VSS 2.85257f
C1848 a_n6400_n19852.n2 VSS 0.81591f
C1849 a_n6400_n19852.t1 VSS 0.27216f
C1850 a_n10800_n21572.n0 VSS 0.82349f
C1851 a_n10800_n21572.t1 VSS 0.12929f
C1852 a_n10800_n21572.n1 VSS 1.96608f
C1853 a_n10800_n21572.t0 VSS 0.18086f
C1854 a_n7157_n21700.t2 VSS 1.01242f
C1855 a_n7157_n21700.t1 VSS 1.00665f
C1856 a_n7157_n21700.n0 VSS 0.5581f
C1857 a_n7157_n21700.t0 VSS 0.15048f
C1858 a_n7157_n21700.n1 VSS 2.16743f
C1859 a_n7157_n21700.t4 VSS 1.04788f
C1860 a_n7157_n21700.n2 VSS 0.36796f
C1861 a_n7157_n21700.t3 VSS 1.05367f
C1862 a_n6400_n21652.t1 VSS 0.27309f
C1863 a_n6400_n21652.t2 VSS 0.16442f
C1864 a_n6400_n21652.t4 VSS 0.31401f
C1865 a_n6400_n21652.t3 VSS 0.31401f
C1866 a_n6400_n21652.n0 VSS 0.94109f
C1867 a_n6400_n21652.n1 VSS 2.78096f
C1868 a_n6400_n21652.n2 VSS 0.82003f
C1869 a_n6400_n21652.t0 VSS 0.27309f
C1870 a_n10800_n23372.n0 VSS 0.78687f
C1871 a_n10800_n23372.t1 VSS 0.12249f
C1872 a_n10800_n23372.n1 VSS 1.87864f
C1873 a_n10800_n23372.t0 VSS 0.17169f
C1874 a_n7157_n23500.t0 VSS 0.98051f
C1875 a_n7157_n23500.t2 VSS 0.94316f
C1876 a_n7157_n23500.t3 VSS 0.9378f
C1877 a_n7157_n23500.n0 VSS 0.51899f
C1878 a_n7157_n23500.t4 VSS 0.13994f
C1879 a_n7157_n23500.n1 VSS 2.01556f
C1880 a_n7157_n23500.n2 VSS 0.34218f
C1881 a_n7157_n23500.t1 VSS 0.97513f
C1882 a_n6400_n23452.t2 VSS 0.30483f
C1883 a_n6400_n23452.t3 VSS 0.26779f
C1884 a_n6400_n23452.t4 VSS 0.26779f
C1885 a_n6400_n23452.n0 VSS 0.81062f
C1886 a_n6400_n23452.t0 VSS 0.16253f
C1887 a_n6400_n23452.n1 VSS 2.74905f
C1888 a_n6400_n23452.n2 VSS 0.93029f
C1889 a_n6400_n23452.t1 VSS 0.30483f
C1890 VSS.t140 VSS 0.08725f
C1891 VSS.t142 VSS 0.08725f
C1892 VSS.t102 VSS 0.08725f
C1893 VSS.t104 VSS 0.08892f
C1894 VSS.t144 VSS 0.08725f
C1895 VSS.t100 VSS 0.08725f
C1896 VSS.t155 VSS 0.12009f
C1897 VSS.t20 VSS 0.11783f
C1898 VSS.t61 VSS 0.11783f
C1899 VSS.t126 VSS 0.12009f
C1900 VSS.t57 VSS 0.11783f
C1901 VSS.t59 VSS 0.11783f
C1902 VSS.t22 VSS 0.11783f
C1903 VSS.t24 VSS 0.11783f
C1904 VSS.t357 VSS 0.20079f
C1905 VSS.t352 VSS 0.19701f
C1906 VSS.t354 VSS 0.19701f
C1907 VSS.t359 VSS 0.19701f
C1908 VSS.t207 VSS 0.14258f
C1909 VSS.t205 VSS 0.1399f
C1910 VSS.t255 VSS 0.08291f
C1911 VSS.t254 VSS 0.08291f
C1912 VSS.t251 VSS 0.08291f
C1913 VSS.t250 VSS 0.0845f
C1914 VSS.t253 VSS 0.08291f
C1915 VSS.t252 VSS 0.08291f
C1916 VSS.t197 VSS 0.1399f
C1917 VSS.t195 VSS 0.14258f
C1918 VSS.t201 VSS 0.1399f
C1919 VSS.t199 VSS 0.1399f
C1920 VSS.t203 VSS 0.1399f
C1921 VSS.t193 VSS 0.1399f
C1922 VSS.t183 VSS 0.16381f
C1923 VSS.t181 VSS 0.16381f
C1924 VSS.t86 VSS 0.20324f
C1925 VSS.t46 VSS 0.20324f
C1926 VSS.t48 VSS 0.20324f
C1927 VSS.t311 VSS 0.20714f
C1928 VSS.t366 VSS 0.11836f
C1929 VSS.t223 VSS 0.11614f
C1930 VSS.t333 VSS 0.11614f
C1931 VSS.t111 VSS 0.11836f
C1932 VSS.t329 VSS 0.11614f
C1933 VSS.t331 VSS 0.11614f
C1934 VSS.t225 VSS 0.11614f
C1935 VSS.t227 VSS 0.11614f
C1936 VSS.t342 VSS 0.09218f
C1937 VSS.t344 VSS 0.09045f
C1938 VSS.t338 VSS 0.09045f
C1939 VSS.t340 VSS 0.09045f
C1940 VSS.t346 VSS 0.09045f
C1941 VSS.t348 VSS 0.09045f
C1942 VSS.t325 VSS 0.03199f
C1943 VSS.t323 VSS 0.03245f
C1944 VSS.t315 VSS 0.03245f
C1945 VSS.t327 VSS 0.03199f
C1946 VSS.t67 VSS 0.05093f
C1947 VSS.t305 VSS 0.05439f
C1948 VSS.t302 VSS 0.05484f
C1949 VSS.t32 VSS 0.05484f
C1950 VSS.t287 VSS 0.05484f
C1951 VSS.t109 VSS 0.05484f
C1952 VSS.t1 VSS 0.05312f
C1953 VSS.t364 VSS 0.08892f
C1954 VSS.t75 VSS 0.08725f
C1955 VSS.t77 VSS 0.08725f
C1956 VSS.t79 VSS 0.08725f
C1957 VSS.t29 VSS 0.08725f
C1958 VSS.t31 VSS 0.08725f
C1959 VSS.t50 VSS 0.12009f
C1960 VSS.t52 VSS 0.11783f
C1961 VSS.t54 VSS 0.11783f
C1962 VSS.t93 VSS 0.11783f
C1963 VSS.t95 VSS 0.11783f
C1964 VSS.t97 VSS 0.11783f
C1965 VSS.t114 VSS 0.11783f
C1966 VSS.t116 VSS 0.12009f
C1967 VSS.t299 VSS 0.19701f
C1968 VSS.t301 VSS 0.20079f
C1969 VSS.t295 VSS 0.19701f
C1970 VSS.t297 VSS 0.19701f
C1971 VSS.t136 VSS 0.14258f
C1972 VSS.t134 VSS 0.1399f
C1973 VSS.t133 VSS 0.1399f
C1974 VSS.t132 VSS 0.1399f
C1975 VSS.t131 VSS 0.1399f
C1976 VSS.t130 VSS 0.1399f
C1977 VSS.t4 VSS 0.0845f
C1978 VSS.t14 VSS 0.08291f
C1979 VSS.t10 VSS 0.08291f
C1980 VSS.t12 VSS 0.08291f
C1981 VSS.t8 VSS 0.08291f
C1982 VSS.t6 VSS 0.08291f
C1983 VSS.t129 VSS 0.1399f
C1984 VSS.t128 VSS 0.14258f
C1985 VSS.t238 VSS 0.16381f
C1986 VSS.t236 VSS 0.16381f
C1987 VSS.t66 VSS 0.20324f
C1988 VSS.t26 VSS 0.20324f
C1989 VSS.t191 VSS 0.20714f
C1990 VSS.t279 VSS 0.20324f
C1991 VSS.t149 VSS 0.11836f
C1992 VSS.t151 VSS 0.11614f
C1993 VSS.t185 VSS 0.11614f
C1994 VSS.t187 VSS 0.11614f
C1995 VSS.t189 VSS 0.11614f
C1996 VSS.t120 VSS 0.11614f
C1997 VSS.t122 VSS 0.11614f
C1998 VSS.t124 VSS 0.11836f
C1999 VSS.t230 VSS 0.09045f
C2000 VSS.t232 VSS 0.09045f
C2001 VSS.t234 VSS 0.09045f
C2002 VSS.t213 VSS 0.09045f
C2003 VSS.t215 VSS 0.09045f
C2004 VSS.t217 VSS 0.09218f
C2005 VSS.t175 VSS 0.03117f
C2006 VSS.t176 VSS 0.03072f
C2007 VSS.t174 VSS 0.03072f
C2008 VSS.t172 VSS 0.03072f
C2009 VSS.t173 VSS 0.03117f
C2010 VSS.t319 VSS 0.03199f
C2011 VSS.t313 VSS 0.03245f
C2012 VSS.t321 VSS 0.03245f
C2013 VSS.t317 VSS 0.03199f
C2014 VSS.t263 VSS 0.03465f
C2015 VSS.t257 VSS 0.03424f
C2016 VSS.t259 VSS 0.03424f
C2017 VSS.t264 VSS 0.03465f
C2018 VSS.t267 VSS 0.03465f
C2019 VSS.t266 VSS 0.03424f
C2020 VSS.t265 VSS 0.03424f
C2021 VSS.t261 VSS 0.03465f
C2022 VSS.t170 VSS 0.03072f
C2023 VSS.t168 VSS 0.03072f
C2024 VSS.t171 VSS 0.03117f
C2025 VSS.t166 VSS 0.03072f
C2026 VSS.t167 VSS 0.03117f
C2027 VDD.n0 VSS 0.20135f
C2028 VDD.n1 VSS 0.08732f
C2029 VDD.n2 VSS 0.10959f
C2030 VDD.n3 VSS 0.10749f
C2031 VDD.n4 VSS 5.24112f
C2032 VDD.n5 VSS 0.10282f
C2033 VDD.n6 VSS 3.66379f
C2034 VDD.t76 VSS 1.37097f
C2035 VDD.n7 VSS 0.28927f
C2036 VDD.n8 VSS 6.85484f
C2037 VDD.n9 VSS 0.10282f
C2038 VDD.n10 VSS 0.10959f
C2039 VDD.n11 VSS 0.10959f
C2040 VDD.n12 VSS 0.10959f
C2041 VDD.n13 VSS 0.10749f
C2042 VDD.n14 VSS 0.10282f
C2043 VDD.t175 VSS 2.05645f
C2044 VDD.n15 VSS 0.28927f
C2045 VDD.t165 VSS 0.41129f
C2046 VDD.t153 VSS 1.37097f
C2047 VDD.n16 VSS 0.20564f
C2048 VDD.t306 VSS 0.1371f
C2049 VDD.t173 VSS 0.27419f
C2050 VDD.t324 VSS 0.47984f
C2051 VDD.t326 VSS 0.54839f
C2052 VDD.t328 VSS 0.47984f
C2053 VDD.t66 VSS 0.27419f
C2054 VDD.t350 VSS 0.27419f
C2055 VDD.t64 VSS 0.27419f
C2056 VDD.t352 VSS 0.27419f
C2057 VDD.t62 VSS 0.27419f
C2058 VDD.t354 VSS 0.27419f
C2059 VDD.t58 VSS 0.27419f
C2060 VDD.t363 VSS 0.27419f
C2061 VDD.t60 VSS 0.47984f
C2062 VDD.t56 VSS 0.54839f
C2063 VDD.t54 VSS 0.54839f
C2064 VDD.t48 VSS 0.41129f
C2065 VDD.t86 VSS 0.41129f
C2066 VDD.t167 VSS 0.54839f
C2067 VDD.t169 VSS 0.54839f
C2068 VDD.t171 VSS 0.41129f
C2069 VDD.t99 VSS 0.41129f
C2070 VDD.t294 VSS 0.54839f
C2071 VDD.t82 VSS 0.54839f
C2072 VDD.t213 VSS 0.54839f
C2073 VDD.t89 VSS 0.54839f
C2074 VDD.t85 VSS 0.54839f
C2075 VDD.t98 VSS 0.54839f
C2076 VDD.n17 VSS 0.10282f
C2077 VDD.n18 VSS 0.10282f
C2078 VDD.n19 VSS 0.10749f
C2079 VDD.n20 VSS 0.10959f
C2080 VDD.n21 VSS 0.10959f
C2081 VDD.n22 VSS 0.10959f
C2082 VDD.n23 VSS 0.10959f
C2083 VDD.n24 VSS 0.10959f
C2084 VDD.n25 VSS 0.10749f
C2085 VDD.n26 VSS 0.10282f
C2086 VDD.t287 VSS 2.19355f
C2087 VDD.t152 VSS 1.37097f
C2088 VDD.t151 VSS 0.54839f
C2089 VDD.t150 VSS 0.54839f
C2090 VDD.t149 VSS 0.41129f
C2091 VDD.n27 VSS 0.27419f
C2092 VDD.t148 VSS 0.41129f
C2093 VDD.t147 VSS 0.54839f
C2094 VDD.t146 VSS 0.54839f
C2095 VDD.t145 VSS 1.37097f
C2096 VDD.t289 VSS 2.19355f
C2097 VDD.t143 VSS 1.37097f
C2098 VDD.t163 VSS 2.05645f
C2099 VDD.n28 VSS 0.10282f
C2100 VDD.n29 VSS 0.10959f
C2101 VDD.n30 VSS 0.10959f
C2102 VDD.n31 VSS 0.10959f
C2103 VDD.n32 VSS 0.10959f
C2104 VDD.n33 VSS 0.10749f
C2105 VDD.n34 VSS 0.10282f
C2106 VDD.n35 VSS 4.79839f
C2107 VDD.n36 VSS 3.47587f
C2108 VDD.n37 VSS 0.28927f
C2109 VDD.n38 VSS 0.46419f
C2110 VDD.t320 VSS 2.05645f
C2111 VDD.n39 VSS 0.10282f
C2112 VDD.n40 VSS 0.10959f
C2113 VDD.n41 VSS 0.29667f
C2114 VDD.t322 VSS 0.54839f
C2115 VDD.t121 VSS 0.54839f
C2116 VDD.t123 VSS 0.54839f
C2117 VDD.t273 VSS 0.54839f
C2118 VDD.t275 VSS 0.54839f
C2119 VDD.t105 VSS 0.54839f
C2120 VDD.t107 VSS 1.37097f
C2121 VDD.n42 VSS 3.67724f
C2122 VDD.n43 VSS 5.24759f
C2123 VDD.n44 VSS 0.09199f
C2124 VDD.n45 VSS 0.10749f
C2125 VDD.n46 VSS 0.10749f
C2126 VDD.n47 VSS 0.10282f
C2127 VDD.n48 VSS 1.9879f
C2128 VDD.t201 VSS 0.47984f
C2129 VDD.t199 VSS 3.22178f
C2130 VDD.n49 VSS 6.56055f
C2131 VDD.n50 VSS 6.85484f
C2132 VDD.n51 VSS 0.10282f
C2133 VDD.n52 VSS 0.10749f
C2134 VDD.n53 VSS 0.10749f
C2135 VDD.n54 VSS 0.10749f
C2136 VDD.n55 VSS 0.10282f
C2137 VDD.n56 VSS 0.20564f
C2138 VDD.t83 VSS 0.1371f
C2139 VDD.t161 VSS 0.27419f
C2140 VDD.t195 VSS 0.47984f
C2141 VDD.t70 VSS 0.54839f
C2142 VDD.t100 VSS 0.47984f
C2143 VDD.t38 VSS 0.27419f
C2144 VDD.t87 VSS 0.27419f
C2145 VDD.t40 VSS 0.27419f
C2146 VDD.t127 VSS 0.27419f
C2147 VDD.t42 VSS 0.27419f
C2148 VDD.t393 VSS 0.27419f
C2149 VDD.t36 VSS 0.27419f
C2150 VDD.t197 VSS 0.27419f
C2151 VDD.t44 VSS 0.47984f
C2152 VDD.t46 VSS 0.54839f
C2153 VDD.t50 VSS 0.54839f
C2154 VDD.t52 VSS 0.41129f
C2155 VDD.t305 VSS 0.41129f
C2156 VDD.t304 VSS 0.54839f
C2157 VDD.t303 VSS 0.54839f
C2158 VDD.t302 VSS 0.54839f
C2159 VDD.t301 VSS 0.54839f
C2160 VDD.t300 VSS 0.54839f
C2161 VDD.t366 VSS 0.54839f
C2162 VDD.t365 VSS 0.41129f
C2163 VDD.t129 VSS 0.41129f
C2164 VDD.t131 VSS 0.54839f
C2165 VDD.t133 VSS 0.54839f
C2166 VDD.t135 VSS 0.41129f
C2167 VDD.n57 VSS 0.45974f
C2168 VDD.t137 VSS 0.41129f
C2169 VDD.t139 VSS 0.54839f
C2170 VDD.t141 VSS 0.54839f
C2171 VDD.n58 VSS 0.10282f
C2172 VDD.n59 VSS 0.10749f
C2173 VDD.n60 VSS 0.10749f
C2174 VDD.n61 VSS 0.10749f
C2175 VDD.n62 VSS 0.10282f
C2176 VDD.t155 VSS 0.54839f
C2177 VDD.t157 VSS 0.54839f
C2178 VDD.t159 VSS 0.41129f
C2179 VDD.n63 VSS 0.45974f
C2180 VDD.n64 VSS 0.28927f
C2181 VDD.n65 VSS 0.28927f
C2182 VDD.n66 VSS 3.47587f
C2183 VDD.n67 VSS 4.79839f
C2184 VDD.n68 VSS 0.10282f
C2185 VDD.n69 VSS 0.10749f
C2186 VDD.n70 VSS 0.10749f
C2187 VDD.n71 VSS 0.10749f
C2188 VDD.n72 VSS 0.10282f
C2189 VDD.n73 VSS 6.56055f
C2190 VDD.t109 VSS 3.22178f
C2191 VDD.t119 VSS 0.47984f
C2192 VDD.n74 VSS 1.9879f
C2193 VDD.t102 VSS 2.05645f
C2194 VDD.t391 VSS 0.54839f
C2195 VDD.t389 VSS 0.54839f
C2196 VDD.t216 VSS 0.54839f
C2197 VDD.t214 VSS 0.54839f
C2198 VDD.t265 VSS 0.54839f
C2199 VDD.t263 VSS 0.54839f
C2200 VDD.n75 VSS 0.10282f
C2201 VDD.n76 VSS 0.10749f
C2202 VDD.n77 VSS 0.09416f
C2203 VDD.n78 VSS 0.10818f
C2204 VDD.t176 VSS 0.15443f
C2205 VDD.t174 VSS 0.15446f
C2206 VDD.n79 VSS 0.15876f
C2207 VDD.n80 VSS 0.1778f
C2208 VDD.n81 VSS 0.06189f
C2209 VDD.t67 VSS 0.15347f
C2210 VDD.t65 VSS 0.14972f
C2211 VDD.n82 VSS 0.06198f
C2212 VDD.t63 VSS 0.14972f
C2213 VDD.t59 VSS 0.14972f
C2214 VDD.n83 VSS 0.0615f
C2215 VDD.n84 VSS 0.02769f
C2216 VDD.n85 VSS 0.04105f
C2217 VDD.t53 VSS 0.15347f
C2218 VDD.t51 VSS 0.14972f
C2219 VDD.n86 VSS 0.06198f
C2220 VDD.t47 VSS 0.14972f
C2221 VDD.t45 VSS 0.14972f
C2222 VDD.n87 VSS 0.0615f
C2223 VDD.n88 VSS 0.03117f
C2224 VDD.t37 VSS 0.14972f
C2225 VDD.t43 VSS 0.14972f
C2226 VDD.n89 VSS 0.0615f
C2227 VDD.n90 VSS 0.01417f
C2228 VDD.t198 VSS 0.21902f
C2229 VDD.t394 VSS 0.21512f
C2230 VDD.n91 VSS 0.06198f
C2231 VDD.t128 VSS 0.21512f
C2232 VDD.t88 VSS 0.21512f
C2233 VDD.n92 VSS 0.0615f
C2234 VDD.n93 VSS 0.02856f
C2235 VDD.t162 VSS 0.15443f
C2236 VDD.t164 VSS 0.15446f
C2237 VDD.n94 VSS 0.15876f
C2238 VDD.n95 VSS 0.16391f
C2239 VDD.t321 VSS 0.10407f
C2240 VDD.t323 VSS 0.10233f
C2241 VDD.n96 VSS 0.06198f
C2242 VDD.t122 VSS 0.10233f
C2243 VDD.t124 VSS 0.10233f
C2244 VDD.n97 VSS 0.0615f
C2245 VDD.n98 VSS 0.03117f
C2246 VDD.t274 VSS 0.10233f
C2247 VDD.t276 VSS 0.10233f
C2248 VDD.n99 VSS 0.0615f
C2249 VDD.n100 VSS 0.15418f
C2250 VDD.t106 VSS 0.10233f
C2251 VDD.t108 VSS 0.10407f
C2252 VDD.n101 VSS 0.06418f
C2253 VDD.n102 VSS 0.18236f
C2254 VDD.t200 VSS 0.13023f
C2255 VDD.t202 VSS 0.13023f
C2256 VDD.n103 VSS 0.18128f
C2257 VDD.n104 VSS 0.66253f
C2258 VDD.n105 VSS 0.3062f
C2259 VDD.t196 VSS 0.21512f
C2260 VDD.t84 VSS 0.21512f
C2261 VDD.n106 VSS 0.0615f
C2262 VDD.n107 VSS 0.18145f
C2263 VDD.t101 VSS 0.21512f
C2264 VDD.t71 VSS 0.21512f
C2265 VDD.n108 VSS 0.0615f
C2266 VDD.n109 VSS 0.01331f
C2267 VDD.n110 VSS 0.06813f
C2268 VDD.n111 VSS 0.19702f
C2269 VDD.t41 VSS 0.14972f
C2270 VDD.t39 VSS 0.14979f
C2271 VDD.n112 VSS 0.0615f
C2272 VDD.n113 VSS 0.01733f
C2273 VDD.n114 VSS 0.04626f
C2274 VDD.n115 VSS 0.08446f
C2275 VDD.n116 VSS 0.14463f
C2276 VDD.t271 VSS 0.17568f
C2277 VDD.t270 VSS 0.17571f
C2278 VDD.n117 VSS 0.10186f
C2279 VDD.t144 VSS 0.11395f
C2280 VDD.t142 VSS 0.11395f
C2281 VDD.n118 VSS 0.0615f
C2282 VDD.t132 VSS 0.11395f
C2283 VDD.t130 VSS 0.11672f
C2284 VDD.n119 VSS 0.0615f
C2285 VDD.n120 VSS 0.10661f
C2286 VDD.t136 VSS 0.11395f
C2287 VDD.t134 VSS 0.11395f
C2288 VDD.n121 VSS 0.0615f
C2289 VDD.n122 VSS 0.01765f
C2290 VDD.t140 VSS 0.11395f
C2291 VDD.t138 VSS 0.11395f
C2292 VDD.n123 VSS 0.0615f
C2293 VDD.n124 VSS 0.01765f
C2294 VDD.n125 VSS 0.014f
C2295 VDD.n126 VSS 0.15312f
C2296 VDD.t290 VSS 0.09373f
C2297 VDD.n127 VSS 0.11814f
C2298 VDD.n128 VSS 0.12614f
C2299 VDD.n129 VSS 0.09836f
C2300 VDD.t269 VSS 0.17568f
C2301 VDD.t272 VSS 0.17571f
C2302 VDD.n130 VSS 0.10186f
C2303 VDD.t172 VSS 0.11672f
C2304 VDD.t170 VSS 0.11395f
C2305 VDD.n131 VSS 0.06198f
C2306 VDD.t168 VSS 0.11395f
C2307 VDD.t166 VSS 0.11395f
C2308 VDD.n132 VSS 0.0615f
C2309 VDD.n133 VSS 0.03117f
C2310 VDD.t160 VSS 0.11395f
C2311 VDD.t158 VSS 0.11395f
C2312 VDD.n134 VSS 0.0615f
C2313 VDD.n135 VSS 0.01765f
C2314 VDD.t156 VSS 0.11395f
C2315 VDD.t154 VSS 0.11395f
C2316 VDD.n136 VSS 0.0615f
C2317 VDD.t288 VSS 0.09373f
C2318 VDD.n137 VSS 0.1415f
C2319 VDD.n138 VSS 0.03374f
C2320 VDD.n139 VSS 0.2241f
C2321 VDD.n140 VSS 0.07801f
C2322 VDD.n141 VSS 0.10414f
C2323 VDD.t55 VSS 0.14972f
C2324 VDD.t49 VSS 0.15347f
C2325 VDD.n142 VSS 0.0615f
C2326 VDD.n143 VSS 0.08572f
C2327 VDD.t61 VSS 0.14972f
C2328 VDD.t57 VSS 0.14972f
C2329 VDD.n144 VSS 0.0615f
C2330 VDD.n145 VSS 0.01417f
C2331 VDD.n147 VSS 0.19728f
C2332 VDD.t355 VSS 0.20889f
C2333 VDD.t364 VSS 0.21267f
C2334 VDD.n148 VSS 0.0615f
C2335 VDD.n149 VSS 0.07999f
C2336 VDD.t351 VSS 0.20889f
C2337 VDD.t353 VSS 0.20889f
C2338 VDD.n150 VSS 0.0615f
C2339 VDD.n151 VSS 0.01765f
C2340 VDD.t327 VSS 0.20889f
C2341 VDD.t329 VSS 0.20889f
C2342 VDD.n152 VSS 0.0615f
C2343 VDD.n153 VSS 0.01765f
C2344 VDD.t307 VSS 0.20889f
C2345 VDD.t325 VSS 0.20889f
C2346 VDD.n154 VSS 0.0615f
C2347 VDD.n155 VSS 0.18145f
C2348 VDD.n156 VSS 0.31314f
C2349 VDD.t120 VSS 0.13196f
C2350 VDD.t110 VSS 0.13196f
C2351 VDD.n157 VSS 0.18128f
C2352 VDD.n158 VSS 0.3538f
C2353 VDD.n159 VSS 0.17561f
C2354 VDD.t77 VSS 0.1008f
C2355 VDD.t264 VSS 0.09913f
C2356 VDD.n160 VSS 0.06198f
C2357 VDD.t266 VSS 0.09913f
C2358 VDD.t215 VSS 0.09913f
C2359 VDD.n161 VSS 0.0615f
C2360 VDD.n162 VSS 0.03117f
C2361 VDD.t217 VSS 0.09913f
C2362 VDD.t390 VSS 0.09913f
C2363 VDD.n163 VSS 0.0615f
C2364 VDD.t392 VSS 0.09913f
C2365 VDD.t103 VSS 0.1008f
C2366 VDD.n164 VSS 0.0615f
C2367 VDD.n165 VSS 0.15054f
C2368 VDD.n166 VSS 0.15418f
C2369 VDD.n167 VSS 0.22565f
C2370 VDD.n168 VSS 17.8148f
C2371 VDD.t93 VSS 0.73118f
C2372 VDD.t92 VSS 0.65806f
C2373 VDD.t317 VSS 0.65806f
C2374 VDD.t316 VSS 0.65806f
C2375 VDD.t311 VSS 0.65806f
C2376 VDD.t310 VSS 0.65806f
C2377 VDD.t81 VSS 0.65806f
C2378 VDD.t80 VSS 0.65806f
C2379 VDD.t299 VSS 0.65806f
C2380 VDD.t298 VSS 0.65806f
C2381 VDD.t114 VSS 0.65806f
C2382 VDD.t113 VSS 0.65806f
C2383 VDD.t3 VSS 0.65806f
C2384 VDD.t2 VSS 0.37098f
C2385 VDD.t1 VSS 0.08073f
C2386 VDD.t112 VSS 0.08257f
C2387 VDD.n169 VSS 0.08272f
C2388 VDD.t0 VSS 0.4827f
C2389 VDD.t296 VSS 0.33417f
C2390 VDD.t297 VSS 0.08257f
C2391 VDD.t79 VSS 0.08257f
C2392 VDD.n170 VSS 0.08272f
C2393 VDD.t308 VSS 0.33417f
C2394 VDD.t309 VSS 0.08257f
C2395 VDD.t315 VSS 0.0821f
C2396 VDD.n171 VSS 0.08272f
C2397 VDD.t90 VSS 0.34623f
C2398 VDD.t91 VSS 0.07837f
C2399 VDD.n172 VSS 0.35829f
C2400 VDD.n173 VSS 0.05712f
C2401 VDD.n174 VSS 0.3426f
C2402 VDD.t314 VSS 0.33417f
C2403 VDD.n175 VSS 0.3426f
C2404 VDD.n176 VSS 0.05712f
C2405 VDD.n177 VSS 0.08272f
C2406 VDD.n178 VSS 0.05712f
C2407 VDD.n179 VSS 0.3426f
C2408 VDD.t78 VSS 0.33417f
C2409 VDD.n180 VSS 0.3426f
C2410 VDD.n181 VSS 0.05712f
C2411 VDD.n182 VSS 0.08272f
C2412 VDD.n183 VSS 0.05712f
C2413 VDD.n184 VSS 0.3426f
C2414 VDD.t111 VSS 0.33417f
C2415 VDD.n185 VSS 0.3426f
C2416 VDD.n186 VSS 0.05712f
C2417 VDD.n187 VSS 0.19458f
C2418 VDD.n188 VSS 2.39157f
C2419 VDD.n189 VSS 23.8556f
C2420 VDD.n190 VSS 0.20136f
C2421 VDD.n191 VSS 0.09416f
C2422 VDD.n192 VSS 0.10749f
C2423 VDD.n193 VSS 0.10282f
C2424 VDD.t193 VSS 0.47984f
C2425 VDD.n194 VSS 0.10282f
C2426 VDD.n195 VSS 0.10749f
C2427 VDD.n196 VSS 0.10959f
C2428 VDD.n197 VSS 0.10749f
C2429 VDD.n198 VSS 0.10282f
C2430 VDD.n199 VSS 4.79839f
C2431 VDD.n200 VSS 0.28927f
C2432 VDD.t369 VSS 0.1371f
C2433 VDD.n201 VSS 0.10282f
C2434 VDD.n202 VSS 0.10749f
C2435 VDD.n203 VSS 0.10959f
C2436 VDD.n204 VSS 0.10749f
C2437 VDD.n205 VSS 0.10282f
C2438 VDD.t244 VSS 0.54839f
C2439 VDD.n206 VSS 0.10282f
C2440 VDD.n207 VSS 0.10749f
C2441 VDD.n208 VSS 0.10959f
C2442 VDD.n209 VSS 0.10749f
C2443 VDD.n210 VSS 0.10282f
C2444 VDD.t258 VSS 2.05645f
C2445 VDD.t209 VSS 0.41129f
C2446 VDD.n211 VSS 0.46418f
C2447 VDD.n212 VSS 6.56055f
C2448 VDD.n213 VSS 0.10282f
C2449 VDD.n214 VSS 0.10749f
C2450 VDD.n215 VSS 0.09199f
C2451 VDD.n216 VSS 0.10749f
C2452 VDD.n217 VSS 0.10282f
C2453 VDD.n218 VSS 5.24759f
C2454 VDD.n219 VSS 3.67725f
C2455 VDD.t346 VSS 1.37097f
C2456 VDD.t348 VSS 0.54839f
C2457 VDD.t338 VSS 0.54839f
C2458 VDD.t340 VSS 0.54839f
C2459 VDD.t342 VSS 0.54839f
C2460 VDD.t344 VSS 0.54839f
C2461 VDD.t330 VSS 0.54839f
C2462 VDD.t332 VSS 2.05645f
C2463 VDD.t117 VSS 3.22178f
C2464 VDD.t115 VSS 0.47984f
C2465 VDD.n220 VSS 1.9879f
C2466 VDD.n221 VSS 0.10282f
C2467 VDD.n222 VSS 0.10749f
C2468 VDD.n223 VSS 0.29667f
C2469 VDD.n224 VSS 0.10959f
C2470 VDD.n225 VSS 0.10959f
C2471 VDD.n226 VSS 0.10749f
C2472 VDD.n227 VSS 0.10282f
C2473 VDD.n228 VSS 6.85484f
C2474 VDD.n229 VSS 4.79839f
C2475 VDD.n230 VSS 3.47587f
C2476 VDD.n231 VSS 0.28927f
C2477 VDD.n232 VSS 0.28927f
C2478 VDD.n233 VSS 0.45974f
C2479 VDD.t211 VSS 0.41129f
C2480 VDD.t248 VSS 0.54839f
C2481 VDD.t250 VSS 0.54839f
C2482 VDD.t252 VSS 0.41129f
C2483 VDD.t360 VSS 0.41129f
C2484 VDD.t335 VSS 0.54839f
C2485 VDD.t334 VSS 0.54839f
C2486 VDD.t362 VSS 0.54839f
C2487 VDD.t361 VSS 0.54839f
C2488 VDD.t337 VSS 0.54839f
C2489 VDD.t336 VSS 0.54839f
C2490 VDD.t371 VSS 0.41129f
C2491 VDD.t22 VSS 0.41129f
C2492 VDD.t28 VSS 0.54839f
C2493 VDD.t26 VSS 0.54839f
C2494 VDD.t24 VSS 0.47984f
C2495 VDD.t386 VSS 0.27419f
C2496 VDD.t20 VSS 0.27419f
C2497 VDD.t279 VSS 0.27419f
C2498 VDD.t30 VSS 0.27419f
C2499 VDD.t277 VSS 0.27419f
C2500 VDD.t32 VSS 0.27419f
C2501 VDD.t187 VSS 0.27419f
C2502 VDD.t34 VSS 0.27419f
C2503 VDD.t185 VSS 0.47984f
C2504 VDD.t191 VSS 0.54839f
C2505 VDD.t189 VSS 0.47984f
C2506 VDD.t256 VSS 0.27419f
C2507 VDD.t318 VSS 0.1371f
C2508 VDD.n234 VSS 0.20564f
C2509 VDD.n235 VSS 0.10282f
C2510 VDD.n236 VSS 0.10749f
C2511 VDD.n237 VSS 0.10959f
C2512 VDD.n238 VSS 0.10959f
C2513 VDD.n239 VSS 0.10959f
C2514 VDD.n240 VSS 0.10749f
C2515 VDD.n241 VSS 0.10282f
C2516 VDD.t242 VSS 0.54839f
C2517 VDD.t240 VSS 1.37097f
C2518 VDD.t283 VSS 2.19355f
C2519 VDD.t239 VSS 1.37097f
C2520 VDD.t238 VSS 0.54839f
C2521 VDD.t237 VSS 0.54839f
C2522 VDD.t208 VSS 0.41129f
C2523 VDD.n242 VSS 0.27419f
C2524 VDD.t207 VSS 0.41129f
C2525 VDD.t236 VSS 0.54839f
C2526 VDD.t235 VSS 0.54839f
C2527 VDD.t234 VSS 1.37097f
C2528 VDD.t285 VSS 2.19355f
C2529 VDD.t228 VSS 1.37097f
C2530 VDD.t254 VSS 0.27419f
C2531 VDD.t374 VSS 0.47984f
C2532 VDD.t372 VSS 0.54839f
C2533 VDD.t378 VSS 0.47984f
C2534 VDD.t6 VSS 0.27419f
C2535 VDD.t376 VSS 0.27419f
C2536 VDD.t4 VSS 0.27419f
C2537 VDD.t382 VSS 0.27419f
C2538 VDD.t8 VSS 0.27419f
C2539 VDD.t380 VSS 0.27419f
C2540 VDD.t10 VSS 0.27419f
C2541 VDD.t384 VSS 0.27419f
C2542 VDD.t12 VSS 0.47984f
C2543 VDD.t14 VSS 0.54839f
C2544 VDD.t16 VSS 0.54839f
C2545 VDD.t18 VSS 0.41129f
C2546 VDD.t260 VSS 0.41129f
C2547 VDD.t69 VSS 0.54839f
C2548 VDD.t68 VSS 0.54839f
C2549 VDD.t268 VSS 0.54839f
C2550 VDD.t267 VSS 0.54839f
C2551 VDD.t97 VSS 0.54839f
C2552 VDD.t96 VSS 0.54839f
C2553 VDD.t388 VSS 0.41129f
C2554 VDD.t220 VSS 0.41129f
C2555 VDD.t222 VSS 0.54839f
C2556 VDD.t224 VSS 0.54839f
C2557 VDD.t203 VSS 0.41129f
C2558 VDD.n243 VSS 0.45974f
C2559 VDD.t205 VSS 0.41129f
C2560 VDD.t230 VSS 0.54839f
C2561 VDD.t232 VSS 0.54839f
C2562 VDD.n244 VSS 0.10282f
C2563 VDD.n245 VSS 0.10749f
C2564 VDD.n246 VSS 0.10959f
C2565 VDD.n247 VSS 0.10959f
C2566 VDD.n248 VSS 0.10959f
C2567 VDD.n249 VSS 0.10749f
C2568 VDD.n250 VSS 0.10282f
C2569 VDD.n251 VSS 0.20564f
C2570 VDD.t218 VSS 2.05645f
C2571 VDD.n252 VSS 3.47587f
C2572 VDD.n253 VSS 0.28927f
C2573 VDD.n254 VSS 0.28927f
C2574 VDD.t125 VSS 3.22178f
C2575 VDD.n255 VSS 6.56055f
C2576 VDD.n256 VSS 6.85484f
C2577 VDD.n257 VSS 0.10282f
C2578 VDD.n258 VSS 0.10749f
C2579 VDD.n259 VSS 0.10959f
C2580 VDD.n260 VSS 0.10959f
C2581 VDD.n261 VSS 0.10959f
C2582 VDD.n262 VSS 0.10749f
C2583 VDD.n263 VSS 0.10282f
C2584 VDD.n264 VSS 1.9879f
C2585 VDD.t178 VSS 2.05645f
C2586 VDD.t180 VSS 0.54839f
C2587 VDD.t182 VSS 0.54839f
C2588 VDD.t356 VSS 0.54839f
C2589 VDD.t358 VSS 0.54839f
C2590 VDD.t72 VSS 0.54839f
C2591 VDD.t74 VSS 0.54839f
C2592 VDD.t367 VSS 1.37097f
C2593 VDD.n265 VSS 3.66378f
C2594 VDD.n266 VSS 5.24112f
C2595 VDD.n267 VSS 0.08732f
C2596 VDD.n268 VSS 0.10818f
C2597 VDD.t255 VSS 0.15446f
C2598 VDD.t219 VSS 0.15443f
C2599 VDD.n269 VSS 0.15876f
C2600 VDD.n270 VSS 0.1778f
C2601 VDD.n271 VSS 0.06189f
C2602 VDD.n272 VSS 0.04105f
C2603 VDD.t347 VSS 0.10407f
C2604 VDD.t349 VSS 0.10233f
C2605 VDD.n273 VSS 0.06418f
C2606 VDD.t331 VSS 0.10233f
C2607 VDD.t333 VSS 0.10407f
C2608 VDD.n274 VSS 0.06198f
C2609 VDD.t343 VSS 0.10233f
C2610 VDD.t345 VSS 0.10233f
C2611 VDD.n275 VSS 0.0615f
C2612 VDD.n276 VSS 0.03117f
C2613 VDD.t339 VSS 0.10233f
C2614 VDD.t341 VSS 0.10233f
C2615 VDD.n277 VSS 0.0615f
C2616 VDD.n278 VSS 0.15418f
C2617 VDD.n279 VSS 0.18236f
C2618 VDD.t116 VSS 0.13023f
C2619 VDD.t118 VSS 0.13023f
C2620 VDD.n280 VSS 0.18128f
C2621 VDD.n281 VSS 0.66253f
C2622 VDD.t259 VSS 0.15446f
C2623 VDD.t257 VSS 0.15443f
C2624 VDD.n282 VSS 0.15876f
C2625 VDD.n283 VSS 0.16391f
C2626 VDD.n284 VSS 0.3062f
C2627 VDD.t319 VSS 0.21512f
C2628 VDD.t190 VSS 0.21512f
C2629 VDD.n285 VSS 0.0615f
C2630 VDD.n286 VSS 0.18145f
C2631 VDD.t192 VSS 0.21512f
C2632 VDD.t186 VSS 0.21512f
C2633 VDD.n287 VSS 0.0615f
C2634 VDD.n288 VSS 0.01331f
C2635 VDD.t280 VSS 0.21512f
C2636 VDD.t387 VSS 0.21902f
C2637 VDD.n289 VSS 0.06198f
C2638 VDD.t188 VSS 0.21512f
C2639 VDD.t278 VSS 0.21512f
C2640 VDD.n290 VSS 0.0615f
C2641 VDD.n291 VSS 0.02856f
C2642 VDD.n292 VSS 0.06813f
C2643 VDD.n293 VSS 0.19702f
C2644 VDD.t35 VSS 0.14979f
C2645 VDD.t33 VSS 0.14972f
C2646 VDD.n294 VSS 0.0615f
C2647 VDD.n295 VSS 0.01733f
C2648 VDD.t29 VSS 0.14972f
C2649 VDD.t23 VSS 0.15347f
C2650 VDD.n296 VSS 0.06198f
C2651 VDD.t25 VSS 0.14972f
C2652 VDD.t27 VSS 0.14972f
C2653 VDD.n297 VSS 0.0615f
C2654 VDD.n298 VSS 0.03117f
C2655 VDD.t31 VSS 0.14972f
C2656 VDD.t21 VSS 0.14972f
C2657 VDD.n299 VSS 0.0615f
C2658 VDD.n300 VSS 0.01417f
C2659 VDD.n301 VSS 0.04626f
C2660 VDD.n302 VSS 0.08446f
C2661 VDD.n303 VSS 0.14463f
C2662 VDD.t212 VSS 0.17571f
C2663 VDD.t210 VSS 0.17568f
C2664 VDD.n304 VSS 0.10186f
C2665 VDD.t253 VSS 0.11672f
C2666 VDD.t251 VSS 0.11395f
C2667 VDD.n305 VSS 0.0615f
C2668 VDD.n306 VSS 0.10661f
C2669 VDD.t249 VSS 0.11395f
C2670 VDD.t247 VSS 0.11395f
C2671 VDD.n307 VSS 0.0615f
C2672 VDD.n308 VSS 0.01765f
C2673 VDD.t246 VSS 0.11395f
C2674 VDD.t245 VSS 0.11395f
C2675 VDD.n309 VSS 0.0615f
C2676 VDD.n310 VSS 0.01765f
C2677 VDD.t243 VSS 0.11395f
C2678 VDD.t241 VSS 0.11395f
C2679 VDD.n311 VSS 0.0615f
C2680 VDD.n312 VSS 0.014f
C2681 VDD.n313 VSS 0.15312f
C2682 VDD.t284 VSS 0.09373f
C2683 VDD.n314 VSS 0.11814f
C2684 VDD.n315 VSS 0.12614f
C2685 VDD.n316 VSS 0.09836f
C2686 VDD.t206 VSS 0.17571f
C2687 VDD.t204 VSS 0.17568f
C2688 VDD.n317 VSS 0.10186f
C2689 VDD.t286 VSS 0.09373f
C2690 VDD.n318 VSS 0.1415f
C2691 VDD.t223 VSS 0.11395f
C2692 VDD.t221 VSS 0.11672f
C2693 VDD.n319 VSS 0.06198f
C2694 VDD.t226 VSS 0.11395f
C2695 VDD.t225 VSS 0.11395f
C2696 VDD.n320 VSS 0.0615f
C2697 VDD.n321 VSS 0.03117f
C2698 VDD.t231 VSS 0.11395f
C2699 VDD.t227 VSS 0.11395f
C2700 VDD.n322 VSS 0.0615f
C2701 VDD.n323 VSS 0.01765f
C2702 VDD.t229 VSS 0.11395f
C2703 VDD.t233 VSS 0.11395f
C2704 VDD.n324 VSS 0.0615f
C2705 VDD.n325 VSS 0.03374f
C2706 VDD.n326 VSS 0.2241f
C2707 VDD.n327 VSS 0.07801f
C2708 VDD.n328 VSS 0.10414f
C2709 VDD.t19 VSS 0.15347f
C2710 VDD.t17 VSS 0.14972f
C2711 VDD.n329 VSS 0.0615f
C2712 VDD.n330 VSS 0.08572f
C2713 VDD.t15 VSS 0.14972f
C2714 VDD.t13 VSS 0.14972f
C2715 VDD.n331 VSS 0.0615f
C2716 VDD.n332 VSS 0.01417f
C2717 VDD.t5 VSS 0.14972f
C2718 VDD.t7 VSS 0.15347f
C2719 VDD.n333 VSS 0.06198f
C2720 VDD.t11 VSS 0.14972f
C2721 VDD.t9 VSS 0.14972f
C2722 VDD.n334 VSS 0.0615f
C2723 VDD.n335 VSS 0.02769f
C2724 VDD.n337 VSS 0.19728f
C2725 VDD.t385 VSS 0.21267f
C2726 VDD.t381 VSS 0.20889f
C2727 VDD.n338 VSS 0.0615f
C2728 VDD.n339 VSS 0.07999f
C2729 VDD.t383 VSS 0.20889f
C2730 VDD.t377 VSS 0.20889f
C2731 VDD.n340 VSS 0.0615f
C2732 VDD.n341 VSS 0.01765f
C2733 VDD.t379 VSS 0.20889f
C2734 VDD.t373 VSS 0.20889f
C2735 VDD.n342 VSS 0.0615f
C2736 VDD.n343 VSS 0.01765f
C2737 VDD.t375 VSS 0.20889f
C2738 VDD.t370 VSS 0.20889f
C2739 VDD.n344 VSS 0.0615f
C2740 VDD.n345 VSS 0.18145f
C2741 VDD.n346 VSS 0.31314f
C2742 VDD.t126 VSS 0.13196f
C2743 VDD.t194 VSS 0.13196f
C2744 VDD.n347 VSS 0.18128f
C2745 VDD.n348 VSS 0.3538f
C2746 VDD.n349 VSS 0.17561f
C2747 VDD.t179 VSS 0.1008f
C2748 VDD.t181 VSS 0.09913f
C2749 VDD.n350 VSS 0.0615f
C2750 VDD.n351 VSS 0.15054f
C2751 VDD.t75 VSS 0.09913f
C2752 VDD.t368 VSS 0.1008f
C2753 VDD.n352 VSS 0.06198f
C2754 VDD.t359 VSS 0.09913f
C2755 VDD.t73 VSS 0.09913f
C2756 VDD.n353 VSS 0.0615f
C2757 VDD.n354 VSS 0.03117f
C2758 VDD.t183 VSS 0.09913f
C2759 VDD.t357 VSS 0.09913f
C2760 VDD.n355 VSS 0.0615f
C2761 VDD.n356 VSS 0.15418f
C2762 VDD.n357 VSS 0.22565f
C2763 VDD.n358 VSS 9.27921f
C2764 VDD.t262 VSS 0.05257f
C2765 VDD.t281 VSS 0.04482f
C2766 VDD.n359 VSS 0.51796f
C2767 VDD.t261 VSS 0.04482f
C2768 VDD.n360 VSS 0.56045f
C2769 VDD.t293 VSS 0.04482f
C2770 VDD.n361 VSS 0.66585f
C2771 VDD.t395 VSS 1.45665f
C2772 VDD.t396 VSS 1.74798f
C2773 VDD.t397 VSS 1.74798f
C2774 VDD.t398 VSS 1.33827f
C2775 VDD.t184 VSS 0.03167f
C2776 VDD.t313 VSS 0.03491f
C2777 VDD.n362 VSS 0.20968f
C2778 VDD.t399 VSS 0.03491f
C2779 VDD.n363 VSS 0.10701f
C2780 VDD.t292 VSS 0.03019f
C2781 VDD.n364 VSS 0.13547f
C2782 VDD.t312 VSS 0.03019f
C2783 VDD.n365 VSS 0.23048f
C2784 VDD.t177 VSS 0.03741f
C2785 VDD.n366 VSS 0.20176f
C2786 VDD.t104 VSS 0.03741f
C2787 VDD.n367 VSS 0.20176f
C2788 VDD.t295 VSS 0.03019f
C2789 VDD.n368 VSS 0.15887f
C2790 VDD.n369 VSS 3.01422f
C2791 VDD.t95 VSS 0.04634f
C2792 VDD.t291 VSS 0.04411f
C2793 VDD.n370 VSS 0.47866f
C2794 VDD.t94 VSS 0.04634f
C2795 VDD.t282 VSS 0.04411f
C2796 VDD.n371 VSS 0.23718f
C2797 VDD.n372 VSS 1.43243f
C2798 VDD.n373 VSS 8.22754f
C2799 VDD.n374 VSS 6.18087f
C2800 VDD.n375 VSS 33.1424f
C2801 VDD.n376 VSS 20.2394f
C2802 E_REGEN_CLKB.n0 VSS 0.17442f
C2803 E_REGEN_CLKB.n1 VSS 0.17902f
C2804 E_REGEN_CLKB.n2 VSS 0.12623f
C2805 E_REGEN_CLKB.n3 VSS 0.51908f
C2806 E_REGEN_CLKB.n4 VSS 0.19466f
C2807 E_REGEN_CLKB.n5 VSS 0.12623f
C2808 E_REGEN_CLKB.n6 VSS 0.19466f
C2809 E_REGEN_CLKB.n7 VSS 0.25293f
C2810 E_REGEN_CLKB.n8 VSS 0.27281f
C2811 E_REGEN_CLKB.n9 VSS 0.27281f
C2812 E_REGEN_CLKB.n10 VSS 0.27281f
C2813 E_REGEN_CLKB.n11 VSS 0.53896f
C2814 E_REGEN_CLKB.n12 VSS 0.1816f
C2815 E_REGEN_CLKB.n13 VSS 0.3674f
C2816 E_REGEN_CLKB.n14 VSS 0.19466f
C2817 E_REGEN_CLKB.n15 VSS 0.19466f
C2818 E_REGEN_CLKB.n16 VSS 0.19466f
C2819 E_REGEN_CLKB.n17 VSS 0.19466f
C2820 E_REGEN_CLKB.n18 VSS 0.10635f
C2821 E_REGEN_CLKB.n19 VSS 0.31222f
C2822 E_REGEN_CLKB.n20 VSS 3.4647f
C2823 E_REGEN_CLKB.n21 VSS 0.42082f
C2824 E_REGEN_CLKB.n22 VSS 0.10635f
C2825 E_REGEN_CLKB.n23 VSS 0.19466f
C2826 E_REGEN_CLKB.n24 VSS 0.27281f
C2827 E_REGEN_CLKB.n25 VSS 0.12623f
C2828 E_REGEN_CLKB.n26 VSS 0.12623f
C2829 E_REGEN_CLKB.n27 VSS 0.12623f
C2830 E_REGEN_CLKB.n28 VSS 0.3674f
C2831 E_REGEN_CLKB.n29 VSS 0.27281f
C2832 E_REGEN_CLKB.n30 VSS 0.53896f
C2833 E_REGEN_CLKB.n31 VSS 0.1816f
C2834 E_REGEN_CLKB.n32 VSS 0.19466f
C2835 E_REGEN_CLKB.n33 VSS 0.19466f
C2836 E_REGEN_CLKB.n34 VSS 0.19466f
C2837 E_REGEN_CLKB.n35 VSS 0.19466f
C2838 E_REGEN_CLKB.n36 VSS 0.27281f
C2839 E_REGEN_CLKB.n37 VSS 0.27281f
C2840 E_REGEN_CLKB.n38 VSS 0.25293f
C2841 E_REGEN_CLKB.n39 VSS 0.19466f
C2842 E_REGEN_CLKB.n40 VSS 0.18428f
C2843 E_REGEN_CLKB.n41 VSS 0.18799f
C2844 E_REGEN_CLKB.n42 VSS 2.10871f
C2845 E_REGEN_CLKB.n43 VSS 8.99832f
C2846 O_REGEN_CLKB.n0 VSS 0.17442f
C2847 O_REGEN_CLKB.n1 VSS 0.10635f
C2848 O_REGEN_CLKB.n2 VSS 0.19466f
C2849 O_REGEN_CLKB.n3 VSS 0.27281f
C2850 O_REGEN_CLKB.n4 VSS 0.12623f
C2851 O_REGEN_CLKB.n5 VSS 0.12623f
C2852 O_REGEN_CLKB.n6 VSS 0.3674f
C2853 O_REGEN_CLKB.n7 VSS 0.53896f
C2854 O_REGEN_CLKB.n8 VSS 0.1816f
C2855 O_REGEN_CLKB.n9 VSS 0.19466f
C2856 O_REGEN_CLKB.n10 VSS 0.19466f
C2857 O_REGEN_CLKB.n11 VSS 0.19466f
C2858 O_REGEN_CLKB.n12 VSS 0.27281f
C2859 O_REGEN_CLKB.n13 VSS 0.27281f
C2860 O_REGEN_CLKB.n14 VSS 0.25293f
C2861 O_REGEN_CLKB.n15 VSS 0.19466f
C2862 O_REGEN_CLKB.n16 VSS 0.51908f
C2863 O_REGEN_CLKB.n17 VSS 0.19466f
C2864 O_REGEN_CLKB.n18 VSS 0.17902f
C2865 O_REGEN_CLKB.n19 VSS 0.31222f
C2866 O_REGEN_CLKB.n20 VSS 3.4647f
C2867 O_REGEN_CLKB.n21 VSS 0.42082f
C2868 O_REGEN_CLKB.n22 VSS 0.18428f
C2869 O_REGEN_CLKB.n23 VSS 0.12623f
C2870 O_REGEN_CLKB.n24 VSS 0.12623f
C2871 O_REGEN_CLKB.n25 VSS 0.12623f
C2872 O_REGEN_CLKB.n26 VSS 0.19466f
C2873 O_REGEN_CLKB.n27 VSS 0.25293f
C2874 O_REGEN_CLKB.n28 VSS 0.27281f
C2875 O_REGEN_CLKB.n29 VSS 0.27281f
C2876 O_REGEN_CLKB.n30 VSS 0.27281f
C2877 O_REGEN_CLKB.n31 VSS 0.27281f
C2878 O_REGEN_CLKB.n32 VSS 0.53896f
C2879 O_REGEN_CLKB.n33 VSS 0.1816f
C2880 O_REGEN_CLKB.n34 VSS 0.3674f
C2881 O_REGEN_CLKB.n35 VSS 0.19466f
C2882 O_REGEN_CLKB.n36 VSS 0.19466f
C2883 O_REGEN_CLKB.n37 VSS 0.19466f
C2884 O_REGEN_CLKB.n38 VSS 0.19466f
C2885 O_REGEN_CLKB.n39 VSS 0.19466f
C2886 O_REGEN_CLKB.n40 VSS 0.10635f
C2887 O_REGEN_CLKB.n41 VSS 0.18799f
C2888 O_REGEN_CLKB.n42 VSS 2.10871f
C2889 O_REGEN_CLKB.n43 VSS 8.99832f
C2890 E_REGEN_CLK.n0 VSS 0.81603f
C2891 E_REGEN_CLK.n1 VSS 0.40948f
C2892 E_REGEN_CLK.n2 VSS 0.09347f
C2893 E_REGEN_CLK.n3 VSS 0.14413f
C2894 E_REGEN_CLK.n4 VSS 0.202f
C2895 E_REGEN_CLK.n5 VSS 0.09347f
C2896 E_REGEN_CLK.n6 VSS 0.09347f
C2897 E_REGEN_CLK.n7 VSS 0.09347f
C2898 E_REGEN_CLK.n8 VSS 0.27204f
C2899 E_REGEN_CLK.n9 VSS 0.202f
C2900 E_REGEN_CLK.n10 VSS 0.202f
C2901 E_REGEN_CLK.n11 VSS 0.39907f
C2902 E_REGEN_CLK.n12 VSS 0.13446f
C2903 E_REGEN_CLK.n13 VSS 0.14413f
C2904 E_REGEN_CLK.n14 VSS 0.14413f
C2905 E_REGEN_CLK.n15 VSS 0.14413f
C2906 E_REGEN_CLK.n16 VSS 0.14413f
C2907 E_REGEN_CLK.n17 VSS 0.14413f
C2908 E_REGEN_CLK.n18 VSS 0.202f
C2909 E_REGEN_CLK.n19 VSS 0.202f
C2910 E_REGEN_CLK.n20 VSS 0.31296f
C2911 E_REGEN_CLK.n21 VSS 0.13622f
C2912 E_REGEN_CLK.n22 VSS 0.20443f
C2913 E_REGEN_CLK.n23 VSS 0.09347f
C2914 E_REGEN_CLK.n24 VSS 0.09347f
C2915 E_REGEN_CLK.n25 VSS 0.09347f
C2916 E_REGEN_CLK.n26 VSS 0.09347f
C2917 E_REGEN_CLK.n27 VSS 0.14413f
C2918 E_REGEN_CLK.n28 VSS 0.31296f
C2919 E_REGEN_CLK.n29 VSS 0.202f
C2920 E_REGEN_CLK.n30 VSS 0.202f
C2921 E_REGEN_CLK.n31 VSS 0.202f
C2922 E_REGEN_CLK.n32 VSS 0.202f
C2923 E_REGEN_CLK.n33 VSS 0.202f
C2924 E_REGEN_CLK.n34 VSS 0.39907f
C2925 E_REGEN_CLK.n35 VSS 0.13446f
C2926 E_REGEN_CLK.n36 VSS 0.27204f
C2927 E_REGEN_CLK.n37 VSS 0.14413f
C2928 E_REGEN_CLK.n38 VSS 0.14413f
C2929 E_REGEN_CLK.n39 VSS 0.14413f
C2930 E_REGEN_CLK.n40 VSS 0.14413f
C2931 E_REGEN_CLK.n41 VSS 0.14413f
C2932 E_REGEN_CLK.n42 VSS 0.13622f
C2933 E_REGEN_CLK.n43 VSS 0.20443f
C2934 E_REGEN_CLK.n44 VSS 0.34575f
C2935 E_REGEN_CLK.n45 VSS 1.0827f
C2936 E_REGEN_CLK.n46 VSS 0.07875f
C2937 E_REGEN_CLK.n47 VSS 0.27204f
C2938 E_REGEN_CLK.n48 VSS 0.13446f
C2939 E_REGEN_CLK.n49 VSS 0.14413f
C2940 E_REGEN_CLK.n50 VSS 0.14413f
C2941 E_REGEN_CLK.n51 VSS 0.14413f
C2942 E_REGEN_CLK.n52 VSS 0.13446f
C2943 E_REGEN_CLK.n53 VSS 0.27204f
C2944 E_REGEN_CLK.n54 VSS 0.14413f
C2945 E_REGEN_CLK.n55 VSS 0.14413f
C2946 E_REGEN_CLK.n56 VSS 0.14413f
C2947 E_REGEN_CLK.n57 VSS 0.07875f
C2948 E_REGEN_CLK.n58 VSS 0.51565f
C2949 E_REGEN_CLK.n59 VSS 1.55245f
C2950 E_REGEN_CLK.n60 VSS 2.56147f
C2951 E_REGEN_CLK.n61 VSS 0.33713f
C2952 E_REGEN_CLK.n62 VSS 0.09347f
C2953 E_REGEN_CLK.n63 VSS 0.14413f
C2954 E_REGEN_CLK.n64 VSS 0.202f
C2955 E_REGEN_CLK.n65 VSS 0.14413f
C2956 E_REGEN_CLK.n66 VSS 0.09347f
C2957 E_REGEN_CLK.n67 VSS 0.13446f
C2958 E_REGEN_CLK.n68 VSS 0.14413f
C2959 E_REGEN_CLK.n69 VSS 0.39907f
C2960 E_REGEN_CLK.n70 VSS 0.202f
C2961 E_REGEN_CLK.n71 VSS 0.14413f
C2962 E_REGEN_CLK.n72 VSS 0.27204f
C2963 E_REGEN_CLK.n73 VSS 0.09347f
C2964 E_REGEN_CLK.n74 VSS 0.09347f
C2965 E_REGEN_CLK.n75 VSS 0.14413f
C2966 E_REGEN_CLK.n76 VSS 0.202f
C2967 E_REGEN_CLK.n77 VSS 0.202f
C2968 E_REGEN_CLK.n78 VSS 0.202f
C2969 E_REGEN_CLK.n79 VSS 0.14413f
C2970 E_REGEN_CLK.n80 VSS 0.13622f
C2971 E_REGEN_CLK.n81 VSS 0.16507f
C2972 E_REGEN_CLK.n82 VSS 1.27358f
C2973 E_REGEN_CLK.n83 VSS 1.49761f
C2974 E_REGEN_CLK.n84 VSS 0.57519f
C2975 E_REGEN_CLK.n85 VSS 3.84291f
C2976 O_REGEN_CLK.n0 VSS 0.81603f
C2977 O_REGEN_CLK.n1 VSS 0.40948f
C2978 O_REGEN_CLK.n2 VSS 0.09347f
C2979 O_REGEN_CLK.n3 VSS 0.14413f
C2980 O_REGEN_CLK.n4 VSS 0.202f
C2981 O_REGEN_CLK.n5 VSS 0.09347f
C2982 O_REGEN_CLK.n6 VSS 0.09347f
C2983 O_REGEN_CLK.n7 VSS 0.09347f
C2984 O_REGEN_CLK.n8 VSS 0.27204f
C2985 O_REGEN_CLK.n9 VSS 0.202f
C2986 O_REGEN_CLK.n10 VSS 0.202f
C2987 O_REGEN_CLK.n11 VSS 0.39907f
C2988 O_REGEN_CLK.n12 VSS 0.13446f
C2989 O_REGEN_CLK.n13 VSS 0.14413f
C2990 O_REGEN_CLK.n14 VSS 0.14413f
C2991 O_REGEN_CLK.n15 VSS 0.14413f
C2992 O_REGEN_CLK.n16 VSS 0.14413f
C2993 O_REGEN_CLK.n17 VSS 0.14413f
C2994 O_REGEN_CLK.n18 VSS 0.202f
C2995 O_REGEN_CLK.n19 VSS 0.202f
C2996 O_REGEN_CLK.n20 VSS 0.31296f
C2997 O_REGEN_CLK.n21 VSS 0.13622f
C2998 O_REGEN_CLK.n22 VSS 0.20443f
C2999 O_REGEN_CLK.n23 VSS 0.09347f
C3000 O_REGEN_CLK.n24 VSS 0.14413f
C3001 O_REGEN_CLK.n25 VSS 0.202f
C3002 O_REGEN_CLK.n26 VSS 0.09347f
C3003 O_REGEN_CLK.n27 VSS 0.09347f
C3004 O_REGEN_CLK.n28 VSS 0.09347f
C3005 O_REGEN_CLK.n29 VSS 0.27204f
C3006 O_REGEN_CLK.n30 VSS 0.202f
C3007 O_REGEN_CLK.n31 VSS 0.202f
C3008 O_REGEN_CLK.n32 VSS 0.39907f
C3009 O_REGEN_CLK.n33 VSS 0.13446f
C3010 O_REGEN_CLK.n34 VSS 0.14413f
C3011 O_REGEN_CLK.n35 VSS 0.14413f
C3012 O_REGEN_CLK.n36 VSS 0.14413f
C3013 O_REGEN_CLK.n37 VSS 0.14413f
C3014 O_REGEN_CLK.n38 VSS 0.14413f
C3015 O_REGEN_CLK.n39 VSS 0.202f
C3016 O_REGEN_CLK.n40 VSS 0.202f
C3017 O_REGEN_CLK.n41 VSS 0.31296f
C3018 O_REGEN_CLK.n42 VSS 0.13622f
C3019 O_REGEN_CLK.n43 VSS 0.20443f
C3020 O_REGEN_CLK.n44 VSS 0.34575f
C3021 O_REGEN_CLK.n45 VSS 1.0827f
C3022 O_REGEN_CLK.n46 VSS 0.07875f
C3023 O_REGEN_CLK.n47 VSS 0.27204f
C3024 O_REGEN_CLK.n48 VSS 0.13446f
C3025 O_REGEN_CLK.n49 VSS 0.14413f
C3026 O_REGEN_CLK.n50 VSS 0.14413f
C3027 O_REGEN_CLK.n51 VSS 0.14413f
C3028 O_REGEN_CLK.n52 VSS 0.13446f
C3029 O_REGEN_CLK.n53 VSS 0.27204f
C3030 O_REGEN_CLK.n54 VSS 0.14413f
C3031 O_REGEN_CLK.n55 VSS 0.14413f
C3032 O_REGEN_CLK.n56 VSS 0.14413f
C3033 O_REGEN_CLK.n57 VSS 0.07875f
C3034 O_REGEN_CLK.n58 VSS 0.51565f
C3035 O_REGEN_CLK.n59 VSS 1.55245f
C3036 O_REGEN_CLK.n60 VSS 2.56147f
C3037 O_REGEN_CLK.n61 VSS 0.33713f
C3038 O_REGEN_CLK.n62 VSS 0.09347f
C3039 O_REGEN_CLK.n63 VSS 0.09347f
C3040 O_REGEN_CLK.n64 VSS 0.09347f
C3041 O_REGEN_CLK.n65 VSS 0.09347f
C3042 O_REGEN_CLK.n66 VSS 0.27204f
C3043 O_REGEN_CLK.n67 VSS 0.202f
C3044 O_REGEN_CLK.n68 VSS 0.202f
C3045 O_REGEN_CLK.n69 VSS 0.202f
C3046 O_REGEN_CLK.n70 VSS 0.202f
C3047 O_REGEN_CLK.n71 VSS 0.202f
C3048 O_REGEN_CLK.n72 VSS 0.39907f
C3049 O_REGEN_CLK.n73 VSS 0.13446f
C3050 O_REGEN_CLK.n74 VSS 0.14413f
C3051 O_REGEN_CLK.n75 VSS 0.14413f
C3052 O_REGEN_CLK.n76 VSS 0.14413f
C3053 O_REGEN_CLK.n77 VSS 0.14413f
C3054 O_REGEN_CLK.n78 VSS 0.14413f
C3055 O_REGEN_CLK.n79 VSS 0.14413f
C3056 O_REGEN_CLK.n80 VSS 0.13622f
C3057 O_REGEN_CLK.n81 VSS 0.16507f
C3058 O_REGEN_CLK.n82 VSS 1.27358f
C3059 O_REGEN_CLK.n83 VSS 1.49761f
C3060 O_REGEN_CLK.n84 VSS 0.57519f
C3061 O_REGEN_CLK.n85 VSS 3.84291f
C3062 E_SENSE_CLK.n0 VSS 0.35044f
C3063 E_SENSE_CLK.n1 VSS 0.35044f
C3064 E_SENSE_CLK.n2 VSS 2.18951f
C3065 E_SENSE_CLK.n3 VSS 0.43843f
C3066 E_SENSE_CLK.n4 VSS 2.26622f
C3067 E_SENSE_CLK.n5 VSS 1.65396f
C3068 E_SENSE_CLK.n6 VSS 6.97478f
C3069 O_SENSE_CLK.n0 VSS 0.35044f
C3070 O_SENSE_CLK.n1 VSS 0.35044f
C3071 O_SENSE_CLK.n2 VSS 2.18951f
C3072 O_SENSE_CLK.n3 VSS 0.43843f
C3073 O_SENSE_CLK.n4 VSS 2.26622f
C3074 O_SENSE_CLK.n5 VSS 1.65396f
C3075 O_SENSE_CLK.n6 VSS 6.97478f
C3076 FE_E_P.t12 VSS 1.20892f
C3077 FE_E_P.t13 VSS 0.26551f
C3078 FE_E_P.t2 VSS 0.26551f
C3079 FE_E_P.n0 VSS 0.90615f
C3080 FE_E_P.n1 VSS 0.44691f
C3081 FE_E_P.t1 VSS 1.20892f
C3082 FE_E_P.t11 VSS 0.26551f
C3083 FE_E_P.t0 VSS 0.26551f
C3084 FE_E_P.n2 VSS 0.90615f
C3085 FE_E_P.n3 VSS 0.49808f
C3086 FE_E_P.t3 VSS 0.26551f
C3087 FE_E_P.t10 VSS 0.26551f
C3088 FE_E_P.n4 VSS 0.90615f
C3089 FE_E_P.n5 VSS 0.20884f
C3090 FE_E_P.n6 VSS 0.18132f
C3091 FE_E_P.t6 VSS 1.20676f
C3092 FE_E_P.t4 VSS 0.26551f
C3093 FE_E_P.t5 VSS 0.26551f
C3094 FE_E_P.n7 VSS 0.89947f
C3095 FE_E_P.n8 VSS 0.50692f
C3096 FE_E_P.t8 VSS 0.26551f
C3097 FE_E_P.t9 VSS 0.26551f
C3098 FE_E_P.n9 VSS 0.89947f
C3099 FE_E_P.n10 VSS 0.26669f
C3100 FE_E_P.t7 VSS 1.19689f
C3101 FE_E_P.n11 VSS 0.61971f
C3102 FE_E_P.n12 VSS 1.39758f
C3103 FE_E_N.t2 VSS 1.15761f
C3104 FE_E_N.t9 VSS 0.25477f
C3105 FE_E_N.t10 VSS 0.25477f
C3106 FE_E_N.n0 VSS 0.86715f
C3107 FE_E_N.n1 VSS 0.42768f
C3108 FE_E_N.t3 VSS 1.15761f
C3109 FE_E_N.t11 VSS 0.25477f
C3110 FE_E_N.t12 VSS 0.25477f
C3111 FE_E_N.n2 VSS 0.86715f
C3112 FE_E_N.n3 VSS 0.47665f
C3113 FE_E_N.t7 VSS 0.25477f
C3114 FE_E_N.t8 VSS 0.25477f
C3115 FE_E_N.n4 VSS 0.86715f
C3116 FE_E_N.n5 VSS 0.19985f
C3117 FE_E_N.n6 VSS 0.19421f
C3118 FE_E_N.t13 VSS 1.15554f
C3119 FE_E_N.t4 VSS 0.25477f
C3120 FE_E_N.t5 VSS 0.25477f
C3121 FE_E_N.n7 VSS 0.86076f
C3122 FE_E_N.n8 VSS 0.48511f
C3123 FE_E_N.t6 VSS 0.25477f
C3124 FE_E_N.t0 VSS 0.25477f
C3125 FE_E_N.n9 VSS 0.86076f
C3126 FE_E_N.n10 VSS 0.24297f
C3127 FE_E_N.t1 VSS 1.14672f
C3128 FE_E_N.n11 VSS 0.41431f
C3129 FE_E_N.n12 VSS 1.27687f
C3130 FE_O_P.t5 VSS 1.15761f
C3131 FE_O_P.t6 VSS 0.25477f
C3132 FE_O_P.t7 VSS 0.25477f
C3133 FE_O_P.n0 VSS 0.86715f
C3134 FE_O_P.n1 VSS 0.47665f
C3135 FE_O_P.t11 VSS 0.25477f
C3136 FE_O_P.t12 VSS 0.25477f
C3137 FE_O_P.n2 VSS 0.86715f
C3138 FE_O_P.n3 VSS 0.19985f
C3139 FE_O_P.t13 VSS 1.15761f
C3140 FE_O_P.t0 VSS 0.25477f
C3141 FE_O_P.t1 VSS 0.25477f
C3142 FE_O_P.n4 VSS 0.86715f
C3143 FE_O_P.n5 VSS 0.42768f
C3144 FE_O_P.n6 VSS 0.19421f
C3145 FE_O_P.t8 VSS 1.14672f
C3146 FE_O_P.t4 VSS 1.15554f
C3147 FE_O_P.t2 VSS 0.25477f
C3148 FE_O_P.t3 VSS 0.25477f
C3149 FE_O_P.n7 VSS 0.86076f
C3150 FE_O_P.n8 VSS 0.48511f
C3151 FE_O_P.t9 VSS 0.25477f
C3152 FE_O_P.t10 VSS 0.25477f
C3153 FE_O_P.n9 VSS 0.86076f
C3154 FE_O_P.n10 VSS 0.24297f
C3155 FE_O_P.n11 VSS 0.41431f
C3156 FE_O_P.n12 VSS 1.27687f
C3157 FE_O_N.t8 VSS 1.20893f
C3158 FE_O_N.t9 VSS 0.26551f
C3159 FE_O_N.t2 VSS 0.26551f
C3160 FE_O_N.n0 VSS 0.90615f
C3161 FE_O_N.n1 VSS 0.49808f
C3162 FE_O_N.t3 VSS 0.26551f
C3163 FE_O_N.t4 VSS 0.26551f
C3164 FE_O_N.n2 VSS 0.90615f
C3165 FE_O_N.n3 VSS 0.20884f
C3166 FE_O_N.t1 VSS 1.20893f
C3167 FE_O_N.t5 VSS 0.26551f
C3168 FE_O_N.t0 VSS 0.26551f
C3169 FE_O_N.n4 VSS 0.90615f
C3170 FE_O_N.n5 VSS 0.44691f
C3171 FE_O_N.n6 VSS 0.18132f
C3172 FE_O_N.t10 VSS 1.20676f
C3173 FE_O_N.t11 VSS 0.26551f
C3174 FE_O_N.t12 VSS 0.26551f
C3175 FE_O_N.n7 VSS 0.89947f
C3176 FE_O_N.n8 VSS 0.50692f
C3177 FE_O_N.t13 VSS 0.26551f
C3178 FE_O_N.t6 VSS 0.26551f
C3179 FE_O_N.n9 VSS 0.89947f
C3180 FE_O_N.n10 VSS 0.26669f
C3181 FE_O_N.t7 VSS 1.19689f
C3182 FE_O_N.n11 VSS 0.61971f
C3183 FE_O_N.n12 VSS 1.39758f
C3184 SAMP_E_P.t2 VSS 0.14604f
C3185 SAMP_E_P.n0 VSS 0.40502f
C3186 SAMP_E_P.n1 VSS 0.97957f
C3187 SAMP_E_P.n2 VSS 0.09614f
C3188 SAMP_E_P.t0 VSS 0.34171f
C3189 SAMP_E_P.n3 VSS 0.09849f
C3190 SAMP_E_P.t1 VSS 0.34171f
C3191 SAMP_E_P.n4 VSS 0.09849f
C3192 SAMP_E_P.n5 VSS 0.08374f
C3193 SAMP_E_P.n6 VSS 0.30761f
C3194 SAMP_E_P.t3 VSS 0.34451f
C3195 SAMP_E_P.t4 VSS 0.34441f
C3196 SAMP_E_P.n7 VSS 0.22787f
C3197 SAMP_E_P.n8 VSS 0.72311f
C3198 SAMP_E_P.n9 VSS 1.89647f
C3199 SAMP_E_P.n10 VSS 1.88655f
C3200 SAMP_E_N.t2 VSS 0.10963f
C3201 SAMP_E_N.t3 VSS 0.26998f
C3202 SAMP_E_N.t4 VSS 0.27005f
C3203 SAMP_E_N.n0 VSS 0.17105f
C3204 SAMP_E_N.n1 VSS 0.21765f
C3205 SAMP_E_N.n2 VSS 0.72649f
C3206 SAMP_E_N.n3 VSS 0.0526f
C3207 SAMP_E_N.t1 VSS 0.28004f
C3208 SAMP_E_N.t0 VSS 0.28004f
C3209 SAMP_E_N.n4 VSS 0.07393f
C3210 SAMP_E_N.n5 VSS 0.07393f
C3211 SAMP_E_N.n6 VSS 0.06286f
C3212 SAMP_E_N.n7 VSS 0.23091f
C3213 SAMP_E_N.n8 VSS 0.54281f
C3214 SAMP_E_N.n9 VSS 1.42361f
C3215 SAMP_E_N.n10 VSS 1.12332f
C3216 E_SENSE_BOOST.n0 VSS 0.04667f
C3217 E_SENSE_BOOST.n1 VSS 0.0554f
C3218 E_SENSE_BOOST.n2 VSS 0.16124f
C3219 E_SENSE_BOOST.n3 VSS 0.0797f
C3220 E_SENSE_BOOST.n4 VSS 0.08543f
C3221 E_SENSE_BOOST.n5 VSS 0.08543f
C3222 E_SENSE_BOOST.n6 VSS 0.08543f
C3223 E_SENSE_BOOST.n7 VSS 0.08543f
C3224 E_SENSE_BOOST.n8 VSS 0.08087f
C3225 E_SENSE_BOOST.n9 VSS 1.44212f
C3226 SAMP_O_P.t2 VSS 0.10995f
C3227 SAMP_O_P.n0 VSS 0.28447f
C3228 SAMP_O_P.n1 VSS 0.79165f
C3229 SAMP_O_P.n2 VSS 0.05276f
C3230 SAMP_O_P.t0 VSS 0.28067f
C3231 SAMP_O_P.n3 VSS 0.07415f
C3232 SAMP_O_P.t1 VSS 0.28067f
C3233 SAMP_O_P.n4 VSS 0.07415f
C3234 SAMP_O_P.n5 VSS 0.06304f
C3235 SAMP_O_P.n6 VSS 0.2316f
C3236 SAMP_O_P.t3 VSS 0.26967f
C3237 SAMP_O_P.t4 VSS 0.26959f
C3238 SAMP_O_P.n7 VSS 0.17156f
C3239 SAMP_O_P.n8 VSS 0.54441f
C3240 SAMP_O_P.n9 VSS 1.42782f
C3241 SAMP_O_P.n10 VSS 1.12665f
C3242 SAMP_O_N.t2 VSS 0.14591f
C3243 SAMP_O_N.t0 VSS 0.3452f
C3244 SAMP_O_N.t1 VSS 0.3453f
C3245 SAMP_O_N.n0 VSS 0.22767f
C3246 SAMP_O_N.n1 VSS 0.30724f
C3247 SAMP_O_N.n2 VSS 0.90469f
C3248 SAMP_O_N.n3 VSS 0.09606f
C3249 SAMP_O_N.t3 VSS 0.34157f
C3250 SAMP_O_N.t4 VSS 0.34157f
C3251 SAMP_O_N.n4 VSS 0.0984f
C3252 SAMP_O_N.n5 VSS 0.0984f
C3253 SAMP_O_N.n6 VSS 0.08366f
C3254 SAMP_O_N.n7 VSS 0.30735f
C3255 SAMP_O_N.n8 VSS 0.72247f
C3256 SAMP_O_N.n9 VSS 1.89481f
C3257 SAMP_O_N.n10 VSS 1.8849f
C3258 O_SENSE_BOOST.n0 VSS 0.08087f
C3259 O_SENSE_BOOST.n1 VSS 0.0554f
C3260 O_SENSE_BOOST.n2 VSS 0.08543f
C3261 O_SENSE_BOOST.n3 VSS 0.0797f
C3262 O_SENSE_BOOST.n4 VSS 0.16124f
C3263 O_SENSE_BOOST.n5 VSS 0.08543f
C3264 O_SENSE_BOOST.n6 VSS 0.08543f
C3265 O_SENSE_BOOST.n7 VSS 0.08543f
C3266 O_SENSE_BOOST.n8 VSS 0.04667f
C3267 O_SENSE_BOOST.n9 VSS 1.44212f
C3268 RX_RESTN.n0 VSS 0.13623f
C3269 RX_RESTN.n1 VSS 0.47066f
C3270 RX_RESTN.n2 VSS 2.92409f
C3271 RX_RESTN.t0 VSS 0.11488f
C3272 RX_RESTN.t2 VSS 0.46315f
C3273 RX_RESTN.t1 VSS 0.46315f
C3274 RX_RESTN.n3 VSS 0.20876f
C3275 RX_RESTN.n4 VSS 1.09392f
C3276 RX_RESTP.n0 VSS 0.46983f
C3277 RX_RESTP.n1 VSS 0.21633f
C3278 RX_RESTP.n2 VSS 3.88442f
C3279 RX_RESTP.t0 VSS 0.11779f
C3280 RX_RESTP.t1 VSS 0.46518f
C3281 RX_RESTP.t2 VSS 0.46518f
C3282 RX_RESTP.n3 VSS 0.21405f
C3283 RX_RESTP.n4 VSS 1.08937f
C3284 SAMP_CLK_P.n0 VSS 0.13015f
C3285 SAMP_CLK_P.n1 VSS 0.25013f
C3286 SAMP_CLK_P.n2 VSS 3.73964f
C3287 SAMP_CLK_N.n0 VSS 0.10938f
C3288 SAMP_CLK_N.n1 VSS 0.22229f
C3289 SAMP_CLK_N.n2 VSS 2.93308f
C3290 SAMP_BIAS.n0 VSS 0.02864f
C3291 SAMP_BIAS.n1 VSS 0.03072f
C3292 SAMP_BIAS.n2 VSS 0.03072f
C3293 SAMP_BIAS.n3 VSS 0.02864f
C3294 SAMP_BIAS.n4 VSS 0.25264f
C3295 SAMP_BIAS.n5 VSS 0.02864f
C3296 SAMP_BIAS.n6 VSS 0.03072f
C3297 SAMP_BIAS.n7 VSS 0.03072f
C3298 SAMP_BIAS.n8 VSS 0.02864f
C3299 SAMP_BIAS.n9 VSS 0.08713f
C3300 SAMP_BIAS.n10 VSS 2.16477f
C3301 REST_BIAS.n0 VSS 0.02944f
C3302 REST_BIAS.n1 VSS 0.03128f
C3303 REST_BIAS.n2 VSS 0.03128f
C3304 REST_BIAS.n3 VSS 0.02944f
C3305 REST_BIAS.n4 VSS 0.22195f
C3306 REST_BIAS.n5 VSS 0.02944f
C3307 REST_BIAS.n6 VSS 0.03128f
C3308 REST_BIAS.n7 VSS 0.03128f
C3309 REST_BIAS.n8 VSS 0.02944f
C3310 REST_BIAS.n9 VSS 0.07827f
C3311 REST_BIAS.n10 VSS 1.38426f
C3312 RX_RAWP.n0 VSS 0.50786f
C3313 RX_RAWP.t0 VSS 0.07485f
C3314 RX_RAWP.t3 VSS 0.23743f
C3315 RX_RAWP.t2 VSS 0.18226f
C3316 RX_RAWP.t1 VSS 0.18231f
C3317 RX_RAWP.n1 VSS 0.32417f
C3318 RX_RAWP.n2 VSS 1.0692f
C3319 RX_RAWP.n3 VSS 0.45242f
C3320 RX_RAWN.n0 VSS 0.47865f
C3321 RX_RAWN.t0 VSS 0.07027f
C3322 RX_RAWN.t3 VSS 0.23918f
C3323 RX_RAWN.t2 VSS 0.17321f
C3324 RX_RAWN.t1 VSS 0.17316f
C3325 RX_RAWN.n1 VSS 0.30433f
C3326 RX_RAWN.n2 VSS 1.00377f
C3327 RX_RAWN.n3 VSS 0.42473f
C3328 RX_BW_EN_N.n0 VSS 2.37285f
C3329 RX_BW_EN_N.n1 VSS 1.30569f
C3330 RX_BW_EN_N.n2 VSS 1.47388f
C3331 VTHP.n0 VSS 0.61322f
C3332 VTHN.n0 VSS 0.63951f
C3333 RX_BIAS.n0 VSS 0.02779f
C3334 RX_BIAS.n1 VSS 0.02951f
C3335 RX_BIAS.n2 VSS 0.02951f
C3336 RX_BIAS.n3 VSS 0.02951f
C3337 RX_BIAS.n4 VSS 0.02779f
C3338 RX_BIAS.n5 VSS 0.11903f
C3339 RX_BIAS.n6 VSS 0.01107f
C3340 RX_BIAS.n7 VSS 0.01376f
C3341 RX_BIAS.n8 VSS 0.01376f
C3342 RX_BIAS.n9 VSS 0.01107f
C3343 RX_BIAS.n10 VSS 0.27482f
C3344 RX_BIAS.n11 VSS 0.02779f
C3345 RX_BIAS.n12 VSS 0.02951f
C3346 RX_BIAS.n13 VSS 0.02951f
C3347 RX_BIAS.n14 VSS 0.02951f
C3348 RX_BIAS.n15 VSS 0.02779f
C3349 RX_BIAS.n16 VSS 0.10781f
C3350 RX_BIAS.n17 VSS 0.72566f
C3351 RX_BIAS.n18 VSS 0.71306f
C3352 RXP.t4 VSS 0.17644f
C3353 RXP.n0 VSS 0.53777f
C3354 RXP.n1 VSS 2.23071f
C3355 RXP.t3 VSS 0.03572f
C3356 RXP.t1 VSS 0.03572f
C3357 RXP.t2 VSS 0.03572f
C3358 RXP.t6 VSS 0.03572f
C3359 RXP.t5 VSS 0.03572f
C3360 RXP.t0 VSS 0.03515f
C3361 RXP.t7 VSS 0.05222f
C3362 RXP.n2 VSS 0.77274f
C3363 RXP.n3 VSS 0.46341f
C3364 RXP.n4 VSS 0.46341f
C3365 RXP.n5 VSS 0.46341f
C3366 RXP.n6 VSS 0.46341f
C3367 RXP.n7 VSS 0.42489f
C3368 RXN.t6 VSS 0.07002f
C3369 RXN.n0 VSS 0.21341f
C3370 RXN.n1 VSS 0.88522f
C3371 RXN.t5 VSS 0.01418f
C3372 RXN.t3 VSS 0.01418f
C3373 RXN.t2 VSS 0.01418f
C3374 RXN.t1 VSS 0.01418f
C3375 RXN.t4 VSS 0.01418f
C3376 RXN.t7 VSS 0.01395f
C3377 RXN.t0 VSS 0.02072f
C3378 RXN.n2 VSS 0.30665f
C3379 RXN.n3 VSS 0.1839f
C3380 RXN.n4 VSS 0.1839f
C3381 RXN.n5 VSS 0.1839f
C3382 RXN.n6 VSS 0.1839f
C3383 RXN.n7 VSS 0.16861f
C3384 TERM_EN6_N.n0 VSS 0.40332f
C3385 TERM_EN6_N.n1 VSS 1.74029f
C3386 TERM_EN6_N.n2 VSS 0.71327f
C3387 TERM_EN5_N.n0 VSS 0.41634f
C3388 TERM_EN5_N.n1 VSS 1.79643f
C3389 TERM_EN5_N.n2 VSS 0.73628f
C3390 TERM_EN4_N.n0 VSS 0.41634f
C3391 TERM_EN4_N.n1 VSS 1.79643f
C3392 TERM_EN4_N.n2 VSS 0.73628f
C3393 TERM_EN3_N.n0 VSS 0.41634f
C3394 TERM_EN3_N.n1 VSS 1.79643f
C3395 TERM_EN3_N.n2 VSS 0.73628f
C3396 TERM_EN2_N.n0 VSS 0.41634f
C3397 TERM_EN2_N.n1 VSS 1.79643f
C3398 TERM_EN2_N.n2 VSS 0.73628f
C3399 TERM_EN1_N.n0 VSS 0.41296f
C3400 TERM_EN1_N.n1 VSS 1.78188f
C3401 TERM_EN1_N.n2 VSS 0.73031f
C3402 TERM_EN0_N.n0 VSS 0.38663f
C3403 TERM_EN0_N.n1 VSS 1.66825f
C3404 TERM_EN0_N.n2 VSS 0.68374f
.ends
