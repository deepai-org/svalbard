* PEX produced using /foss/tools/sak/sak-pex.sh with m=3 and s=1 (extresist threshold=0 mOhm, minres=1 mOhm, mindelay=0 ps)
* NGSPICE file created from lane_rx_pi_capture_pex.ext - technology: gf180mcuD

.subckt lane_rx_pi_capture_pex RXP RXN TERM_EN0_N TERM_EN1_N TERM_EN2_N TERM_EN3_N
+ TERM_EN4_N TERM_EN5_N TERM_EN6_N VTHP VTHN RX_BIAS RX_BW_EN_N REST_BIAS SAMP_BIAS
+ E_SENSE_CLK E_REGEN_CLK E_REGEN_CLKB E_CAPTURE_CLK E_CAPTURE_CLKB E_SENSE_BOOST
+ O_SENSE_CLK O_REGEN_CLK O_REGEN_CLKB O_CAPTURE_CLK O_CAPTURE_CLKB O_SENSE_BOOST
+ VDD VSS PHASE_A_P PHASE_A_N PHASE_B_P PHASE_B_N PI_CTRL_A PI_CTRL_B PI_BUF_BIAS
+ CLK_REST_BIAS PI_RAW_P PI_RAW_N PI_CLK_P PI_CLK_N RX_RAWP RX_RAWN RX_RESTP RX_RESTN
+ SAMP_E_P SAMP_E_N SAMP_O_P SAMP_O_N FE_E_P FE_E_N FE_O_P FE_O_N EVEN_Q EVEN_QB ODD_Q
+ ODD_QB
X0 XRX.XFRONT.XFE_O.XP.t6 XRX.XFRONT.XFE_O.SB.t13 XRX.XFRONT.XFE_O.NREGEN.t16 VSS.t464 nfet_03v3 ad=2.08p pd=8.52u as=2.08p ps=8.52u w=8u l=0.28u
X1 XRX.XCAP.O_PRST_TAIL.t1 O_CAPTURE_CLKB.t14 VDD.t89 VDD.t88 pfet_03v3 ad=2.08p pd=8.52u as=2.08p ps=8.52u w=8u l=0.28u
X2 XRX.XCAP.ODD_DB_BUF.t9 FE_O_P.t16 VSS.t128 VSS.t127 nfet_03v3 ad=2.08p pd=8.52u as=2.08p ps=8.52u w=8u l=0.28u
X3 VSS.t321 RX_BIAS.t4 a_2148_n500.t1 VSS.t311 nfet_03v3 ad=2.6p pd=10.52u as=4.4p ps=20.88u w=10u l=0.28u
X4 a_n10800_n17972.t1 TERM_EN3_N.t2 VSS.t15 VSS.t14 nfet_03v3 ad=0.44p pd=2.88u as=0.44p ps=2.88u w=1u l=0.28u
X5 PI_CLK_N.t1 a_66600_32348.t3 a_65148_38800.t5 VSS.t112 nfet_03v3 ad=4.4p pd=20.88u as=2.6p ps=10.52u w=10u l=0.28u
X6 a_12148_44200.t4 SAMP_O_N.t6 SAMP_O_P.t4 VSS.t484 nfet_03v3 ad=1.56p pd=6.52u as=2.64p ps=12.88u w=6u l=0.28u
X7 VSS.t274 E_CAPTURE_CLK.t3 XRX.XCAP.E_RST_TAIL.t8 VSS.t37 nfet_03v3 ad=2.08p pd=8.52u as=2.08p ps=8.52u w=8u l=0.28u
X8 XRX.XFRONT.XFE_E.VREGP.t14 XRX.XFRONT.XFE_E.XN.t51 XRX.XFRONT.XFE_E.XP.t24 VDD.t293 pfet_03v3 ad=2.08p pd=8.52u as=2.08p ps=8.52u w=8u l=0.28u
X9 VDD.t65 XRX.XFRONT.XFE_E.XP.t45 XRX.XFRONT.XFE_E.SXP.t1 VDD.t64 pfet_03v3 ad=2.08p pd=8.52u as=2.08p ps=8.52u w=8u l=0.28u
X10 XRX.XFRONT.XFE_O.SXP.t9 XRX.XFRONT.XFE_O.XP.t46 VDD.t495 VDD.t494 pfet_03v3 ad=2.08p pd=8.52u as=2.08p ps=8.52u w=8u l=0.28u
X11 FE_E_P.t4 XRX.XFRONT.XFE_E.BN.t18 VDD.t180 VDD.t179 pfet_03v3 ad=2.08p pd=8.52u as=2.08p ps=8.52u w=8u l=0.28u
X12 a_80148_31500.t3 PI_BUF_BIAS.t2 VSS.t144 VSS.t143 nfet_03v3 ad=2.6p pd=10.52u as=2.6p ps=10.52u w=10u l=0.28u
X13 VDD.t350 E_CAPTURE_CLKB.t13 XRX.XCAP.E_PRST_TAIL.t6 VDD.t345 pfet_03v3 ad=2.08p pd=8.52u as=2.08p ps=8.52u w=8u l=0.28u
X14 XRX.XCAP.O_RST_TAIL.t1 O_CAPTURE_CLK.t6 VSS.t58 VSS.t57 nfet_03v3 ad=2.08p pd=8.52u as=2.08p ps=8.52u w=8u l=0.28u
X15 VSS.t372 XRX.XCAP.O_QBI.t15 XRX.XCAP.O_QBUF.t2 VSS.t371 nfet_03v3 ad=1.04p pd=4.52u as=1.76p ps=8.88u w=4u l=0.28u
X16 VDD.t435 XRX.XFRONT.XFE_E.BP.t19 FE_E_N.t8 VDD.t434 pfet_03v3 ad=2.08p pd=8.52u as=2.08p ps=8.52u w=8u l=0.28u
X17 XRX.XFRONT.XFE_E.VREGP.t5 E_REGEN_CLKB.t2 VDD.t232 VDD.t231 pfet_03v3 ad=2.08p pd=8.52u as=2.08p ps=8.52u w=8u l=0.28u
X18 VDD.t386 XRX.XFRONT.XFE_O.BP.t17 FE_O_P.t7 VDD.t385 pfet_03v3 ad=2.08p pd=8.52u as=2.08p ps=8.52u w=8u l=0.28u
X19 VDD.t544 O_REGEN_CLK.t17 XRX.XFRONT.XFE_O.XN.t19 VDD.t543 pfet_03v3 ad=2.08p pd=8.52u as=2.08p ps=8.52u w=8u l=0.28u
X20 a_n7157_n21700.t2 a_n10800_n21572.t3 a_n6400_n21652.t2 VSS.t444 nfet_03v3 ad=4.4p pd=20.88u as=2.6p ps=10.52u w=10u l=0.28u
X21 a_66600_32348.t1 PI_RAW_N.t3 a_65148_29400.t4 VSS.t112 nfet_03v3 ad=4.4p pd=20.88u as=2.6p ps=10.52u w=10u l=0.28u
X22 VDD.t573 FE_E_P.t23 XRX.XCAP.EVEN_DB_BUF.t2 VDD.t572 pfet_03v3 ad=2.08p pd=8.52u as=2.08p ps=8.52u w=8u l=0.28u
X23 VSS.t43 O_CAPTURE_CLK.t13 XRX.XCAP.O_SET_TAIL.t2 VSS.t42 nfet_03v3 ad=2.08p pd=8.52u as=2.08p ps=8.52u w=8u l=0.28u
X24 VDD.t28 E_SENSE_CLK.t3 XRX.XFRONT.XFE_E.SA.t0 VDD.t27 pfet_03v3 ad=2.08p pd=8.52u as=3.52p ps=16.88u w=8u l=0.28u
X25 SAMP_E_P.t0 RX_RESTN.t5 a_948_44200.t1 VSS.t11 nfet_03v3 ad=2.64p pd=12.88u as=1.56p ps=6.52u w=6u l=0.28u
X26 XRX.XFRONT.XFE_O.NREGEN.t4 XRX.XFRONT.XFE_O.SB.t10 XRX.XFRONT.XFE_O.XP.t2 VSS.t131 nfet_03v3 ad=2.08p pd=8.52u as=2.08p ps=8.52u w=8u l=0.28u
X27 VSS.t490 FE_E_N.t17 XRX.XCAP.EVEN_D_BUF.t8 VSS.t489 nfet_03v3 ad=2.08p pd=8.52u as=3.52p ps=16.88u w=8u l=0.28u
X28 XRX.XFRONT.XFE_E.VREGN.t15 E_REGEN_CLKB.t8 VDD.t216 VDD.t215 pfet_03v3 ad=3.52p pd=16.88u as=2.08p ps=8.52u w=8u l=0.28u
X29 a_2148_n500.t8 a_n6572_3500.t7 RX_RAWP.t3 VSS.t151 nfet_03v3 ad=1.3p pd=5.52u as=2.2p ps=10.88u w=5u l=0.28u
X30 XRX.XFRONT.XFE_O.SXN.t3 XRX.XFRONT.XFE_O.XN.t38 VSS.t171 VSS.t170 nfet_03v3 ad=3.52p pd=16.88u as=2.08p ps=8.52u w=8u l=0.28u
X31 VDD.t276 E_REGEN_CLK.t13 XRX.XFRONT.XFE_E.XP.t13 VDD.t275 pfet_03v3 ad=2.08p pd=8.52u as=2.08p ps=8.52u w=8u l=0.28u
X32 a_65148_29400.t3 CLK_REST_BIAS.t0 VSS.t80 VSS.t77 nfet_03v3 ad=5.28p pd=24.88u as=3.12p ps=12.52u w=12u l=0.28u
X33 VDD.t394 XRX.XFRONT.XFE_O.XN.t47 XRX.XFRONT.XFE_O.SXN.t6 VDD.t393 pfet_03v3 ad=2.08p pd=8.52u as=2.08p ps=8.52u w=8u l=0.28u
X34 XRX.XCAP.E_RST_TAIL.t11 E_CAPTURE_CLK.t0 VSS.t253 VSS.t252 nfet_03v3 ad=3.52p pd=16.88u as=2.08p ps=8.52u w=8u l=0.28u
X35 VDD.t240 E_REGEN_CLK.t9 XRX.XFRONT.XFE_E.NREGEN.t15 VDD.t239 pfet_03v3 ad=2.08p pd=8.52u as=3.52p ps=16.88u w=8u l=0.28u
X36 XRX.XFRONT.XFE_E.VREGN.t2 XRX.XFRONT.XFE_E.XP.t55 XRX.XFRONT.XFE_E.XN.t11 VDD.t498 pfet_03v3 ad=2.08p pd=8.52u as=2.08p ps=8.52u w=8u l=0.28u
X37 XRX.XFRONT.XFE_E.XP.t33 XRX.XFRONT.XFE_E.XN.t54 XRX.XFRONT.XFE_E.VREGP.t11 VDD.t411 pfet_03v3 ad=2.08p pd=8.52u as=2.08p ps=8.52u w=8u l=0.28u
X38 VDD.t103 O_CAPTURE_CLKB.t1 XRX.XCAP.O_PSET_TAIL.t10 VDD.t94 pfet_03v3 ad=2.08p pd=8.52u as=2.08p ps=8.52u w=8u l=0.28u
X39 a_n5052_2600.t0 VTHN.t1 a_n3600_5641.t3 VSS.t250 nfet_03v3 ad=0.52p pd=2.52u as=0.88p ps=4.88u w=2u l=0.28u
X40 VSS.t302 XRX.XFRONT.XFE_E.SXN.t15 XRX.XFRONT.XFE_E.BN.t6 VSS.t301 nfet_03v3 ad=2.08p pd=8.52u as=2.08p ps=8.52u w=8u l=0.28u
X41 VDD.t130 XRX.XFRONT.XFE_O.XP.t43 XRX.XFRONT.XFE_O.SXP.t0 VDD.t129 pfet_03v3 ad=2.08p pd=8.52u as=2.08p ps=8.52u w=8u l=0.28u
X42 VSS.t532 O_REGEN_CLK.t7 XRX.XFRONT.XFE_O.NREGEN.t23 VSS.t531 nfet_03v3 ad=2.08p pd=8.52u as=3.52p ps=16.88u w=8u l=0.28u
X43 XRX.XFRONT.XFE_O.BN.t8 XRX.XFRONT.XFE_O.SXN.t20 VDD.t486 VDD.t485 pfet_03v3 ad=3.52p pd=16.88u as=2.08p ps=8.52u w=8u l=0.28u
X44 FE_E_N.t13 XRX.XFRONT.XFE_E.BP.t16 VDD.t439 VDD.t438 pfet_03v3 ad=3.52p pd=16.88u as=2.08p ps=8.52u w=8u l=0.28u
X45 RX_RESTN.t2 a_600_22678.t3 a_n852_28800.t5 VSS.t285 nfet_03v3 ad=4.4p pd=20.88u as=2.6p ps=10.52u w=10u l=0.28u
X46 VDD.t226 E_REGEN_CLKB.t5 XRX.XFRONT.XFE_E.VREGP.t2 VDD.t225 pfet_03v3 ad=2.08p pd=8.52u as=2.08p ps=8.52u w=8u l=0.28u
X47 VSS.t314 RX_BIAS.t13 a_n5052_2600.t2 VSS.t313 nfet_03v3 ad=0.52p pd=2.52u as=0.88p ps=4.88u w=2u l=0.28u
X48 XRX.XCAP.ODD_D_BUF.t3 FE_O_N.t22 VDD.t157 VDD.t156 pfet_03v3 ad=2.08p pd=8.52u as=2.08p ps=8.52u w=8u l=0.28u
X49 VSS.t463 XRX.XCAP.E_QI.t15 XRX.XCAP.E_QBBUF.t2 VSS.t462 nfet_03v3 ad=1.04p pd=4.52u as=1.76p ps=8.88u w=4u l=0.28u
X50 XRX.XCAP.E_PSET_TAIL.t11 E_CAPTURE_CLKB.t0 VDD.t364 VDD.t357 pfet_03v3 ad=3.52p pd=16.88u as=2.08p ps=8.52u w=8u l=0.28u
X51 XRX.XCAP.O_SET_TAIL.t5 O_CAPTURE_CLK.t10 VSS.t49 VSS.t48 nfet_03v3 ad=2.08p pd=8.52u as=2.08p ps=8.52u w=8u l=0.28u
X52 FE_E_P.t12 XRX.XFRONT.XFE_E.BN.t12 VSS.t440 VSS.t439 nfet_03v3 ad=2.08p pd=8.52u as=2.08p ps=8.52u w=8u l=0.28u
X53 VDD.t349 E_CAPTURE_CLKB.t7 XRX.XCAP.E_PSET_TAIL.t4 VDD.t347 pfet_03v3 ad=2.08p pd=8.52u as=3.52p ps=16.88u w=8u l=0.28u
X54 a_n6400_n18052.t3 a_n10800_n17972.t2 a_n7300_n18100.t3 VSS.t397 nfet_03v3 ad=2.6p pd=10.52u as=4.4p ps=20.88u w=10u l=0.28u
X55 XRX.XCAP.O_PRST_TAIL.t8 XRX.XCAP.ODD_D_BUF.t19 XRX.XCAP.O_QBI.t4 VDD.t73 pfet_03v3 ad=2.08p pd=8.52u as=3.52p ps=16.88u w=8u l=0.28u
X56 a_65148_38800.t3 CLK_REST_BIAS.t4 VSS.t78 VSS.t77 nfet_03v3 ad=5.28p pd=24.88u as=3.12p ps=12.52u w=12u l=0.28u
X57 VDD.t322 O_REGEN_CLKB.t13 XRX.XFRONT.XFE_O.VREGP.t2 VDD.t321 pfet_03v3 ad=2.08p pd=8.52u as=2.08p ps=8.52u w=8u l=0.28u
X58 XRX.XFRONT.XFE_E.NREGEN.t25 XRX.XFRONT.XFE_E.XN.t36 XRX.XFRONT.XFE_E.XP.t27 VSS.t380 nfet_03v3 ad=2.08p pd=8.52u as=2.08p ps=8.52u w=8u l=0.28u
X59 VDD.t562 XRX.XCAP.O_QBI.t19 XRX.XCAP.O_QBUF.t3 VDD.t561 pfet_03v3 ad=2.08p pd=8.52u as=3.52p ps=16.88u w=8u l=0.28u
X60 a_600_22678.t2 RX_RAWN.t4 a_n852_19400.t6 VSS.t285 nfet_03v3 ad=4.4p pd=20.88u as=2.6p ps=10.52u w=10u l=0.28u
X61 XRX.XFRONT.XFE_E.SXN.t10 XRX.XFRONT.XFE_E.XN.t38 VSS.t546 VSS.t545 nfet_03v3 ad=3.52p pd=16.88u as=2.08p ps=8.52u w=8u l=0.28u
X62 XRX.XFRONT.XFE_E.SB.t6 VSS.t566 VDD.t57 VDD.t56 pfet_03v3 ad=3.52p pd=16.88u as=3.52p ps=16.88u w=8u l=0.28u
X63 VSS.t422 XRX.XFRONT.XFE_O.SXP.t13 XRX.XFRONT.XFE_O.BP.t8 VSS.t421 nfet_03v3 ad=2.08p pd=8.52u as=2.08p ps=8.52u w=8u l=0.28u
X64 XRX.XFRONT.XFE_E.BN.t3 XRX.XFRONT.XFE_E.SXN.t18 VSS.t108 VSS.t107 nfet_03v3 ad=2.08p pd=8.52u as=2.08p ps=8.52u w=8u l=0.28u
X65 XRX.XCAP.E_PRST_TAIL.t1 XRX.XCAP.EVEN_D_BUF.t17 XRX.XCAP.E_QBI.t1 VDD.t1 pfet_03v3 ad=2.08p pd=8.52u as=2.08p ps=8.52u w=8u l=0.28u
X66 a_n852_19400.t5 REST_BIAS.t0 VSS.t163 VSS.t158 nfet_03v3 ad=5.28p pd=24.88u as=3.12p ps=12.52u w=12u l=0.28u
X67 VDD.t59 XRX.XCAP.O_QI.t17 XRX.XCAP.O_QBI.t0 VDD.t58 pfet_03v3 ad=2.08p pd=8.52u as=3.52p ps=16.88u w=8u l=0.28u
X68 XRX.XFRONT.XFE_O.VREGN.t3 O_REGEN_CLKB.t4 VDD.t336 VDD.t335 pfet_03v3 ad=2.08p pd=8.52u as=2.08p ps=8.52u w=8u l=0.28u
X69 a_n6400_n12652.t0 RXN.t1 VSS.t68 ppolyf_u r_width=1u r_length=1u
X70 VSS.t332 E_REGEN_CLK.t7 XRX.XFRONT.XFE_E.NREGEN.t17 VSS.t331 nfet_03v3 ad=2.08p pd=8.52u as=3.52p ps=16.88u w=8u l=0.28u
X71 RXP.t2 a_n7157_n23500.t0 VSS.t32 ppolyf_u r_width=1u r_length=2.43u
X72 VSS.t217 XRX.XFRONT.XFE_E.XP.t39 XRX.XFRONT.XFE_E.SXP.t7 VSS.t216 nfet_03v3 ad=2.08p pd=8.52u as=2.08p ps=8.52u w=8u l=0.28u
X73 XRX.XCAP.E_RST_TAIL.t5 E_CAPTURE_CLK.t6 VSS.t271 VSS.t270 nfet_03v3 ad=2.08p pd=8.52u as=2.08p ps=8.52u w=8u l=0.28u
X74 a_n5052_2600.t3 RX_BIAS.t12 VSS.t315 VSS.t313 nfet_03v3 ad=0.52p pd=2.52u as=0.52p ps=2.52u w=2u l=0.28u
X75 XRX.XFRONT.XFE_O.SXP.t2 XRX.XFRONT.XFE_O.XP.t40 VSS.t197 VSS.t196 nfet_03v3 ad=2.08p pd=8.52u as=2.08p ps=8.52u w=8u l=0.28u
X76 XRX.XCAP.EVEN_D_BUF.t1 FE_E_N.t24 VDD.t474 VDD.t473 pfet_03v3 ad=2.08p pd=8.52u as=2.08p ps=8.52u w=8u l=0.28u
X77 XRX.XFRONT.XFE_E.SXP.t2 XRX.XFRONT.XFE_E.XP.t46 VDD.t67 VDD.t66 pfet_03v3 ad=2.08p pd=8.52u as=2.08p ps=8.52u w=8u l=0.28u
X78 XRX.XCAP.E_QBI.t9 XRX.XCAP.E_QI.t16 VDD.t304 VDD.t303 pfet_03v3 ad=3.52p pd=16.88u as=2.08p ps=8.52u w=8u l=0.28u
X79 VSS.t521 XRX.XCAP.O_QBBUF.t6 ODD_Q.t6 VSS.t520 nfet_03v3 ad=2.08p pd=8.52u as=3.52p ps=16.88u w=8u l=0.28u
X80 XRX.XCAP.EVEN_DB_BUF.t9 FE_E_P.t16 VSS.t558 VSS.t557 nfet_03v3 ad=2.08p pd=8.52u as=2.08p ps=8.52u w=8u l=0.28u
X81 VDD.t260 E_REGEN_CLK.t29 XRX.XFRONT.XFE_E.XN.t23 VDD.t259 pfet_03v3 ad=2.08p pd=8.52u as=2.08p ps=8.52u w=8u l=0.28u
X82 VDD.t196 PI_CLK_P.t0 VSS.t26 ppolyf_u r_width=2u r_length=7.5u
X83 XRX.XFRONT.XFE_O.XN.t3 XRX.XFRONT.XFE_O.SA.t7 XRX.XFRONT.XFE_O.NREGEN.t7 VSS.t194 nfet_03v3 ad=3.52p pd=16.88u as=2.08p ps=8.52u w=8u l=0.28u
X84 EVEN_QB.t2 XRX.XCAP.E_QBUF.t9 VDD.t310 VDD.t309 pfet_03v3 ad=2.08p pd=8.52u as=2.08p ps=8.52u w=8u l=0.28u
X85 a_n852_28800.t3 REST_BIAS.t4 VSS.t159 VSS.t158 nfet_03v3 ad=5.28p pd=24.88u as=3.12p ps=12.52u w=12u l=0.28u
X86 VDD.t464 XRX.XCAP.O_QBBUF.t10 ODD_Q.t3 VDD.t463 pfet_03v3 ad=2.08p pd=8.52u as=3.52p ps=16.88u w=8u l=0.28u
X87 VDD.t100 O_CAPTURE_CLKB.t5 XRX.XCAP.O_PSET_TAIL.t6 VDD.t85 pfet_03v3 ad=2.08p pd=8.52u as=2.08p ps=8.52u w=8u l=0.28u
X88 FE_O_P.t12 XRX.XFRONT.XFE_O.BP.t14 VSS.t407 VSS.t406 nfet_03v3 ad=2.08p pd=8.52u as=2.08p ps=8.52u w=8u l=0.28u
X89 XRX.XCAP.EVEN_D_BUF.t11 FE_E_N.t14 VSS.t492 VSS.t491 nfet_03v3 ad=3.52p pd=16.88u as=2.08p ps=8.52u w=8u l=0.28u
X90 VDD.t340 O_REGEN_CLKB.t1 XRX.XFRONT.XFE_O.VREGN.t6 VDD.t339 pfet_03v3 ad=2.08p pd=8.52u as=2.08p ps=8.52u w=8u l=0.28u
X91 VSS.t72 CLK_REST_BIAS.t3 a_65148_29400.t0 VSS.t71 nfet_03v3 ad=3.12p pd=12.52u as=5.28p ps=24.88u w=12u l=0.28u
X92 VSS.t169 XRX.XFRONT.XFE_O.XN.t41 XRX.XFRONT.XFE_O.SXN.t0 VSS.t168 nfet_03v3 ad=2.08p pd=8.52u as=3.52p ps=16.88u w=8u l=0.28u
X93 XRX.XFRONT.XFE_E.XN.t5 XRX.XFRONT.XFE_E.XP.t52 XRX.XFRONT.XFE_E.VREGN.t5 VDD.t135 pfet_03v3 ad=2.08p pd=8.52u as=2.08p ps=8.52u w=8u l=0.28u
X94 XRX.XFRONT.XFE_E.NTAIL.t3 SAMP_E_P.t8 XRX.XFRONT.XFE_E.SB.t4 VSS.t119 nfet_03v3 ad=2.08p pd=8.52u as=3.52p ps=16.88u w=8u l=0.28u
X95 a_n10800_n23372.t1 TERM_EN0_N.t2 VSS.t396 VSS.t14 nfet_03v3 ad=0.44p pd=2.88u as=0.44p ps=2.88u w=1u l=0.28u
X96 VDD.t8 a_65000_32348.t0 VSS.t26 ppolyf_u r_width=2u r_length=7.5u
X97 XRX.XFRONT.XFE_E.NREGEN.t7 XRX.XFRONT.XFE_E.SB.t10 XRX.XFRONT.XFE_E.XP.t2 VSS.t181 nfet_03v3 ad=2.08p pd=8.52u as=2.08p ps=8.52u w=8u l=0.28u
X98 XRX.XFRONT.XFE_E.BN.t9 XRX.XFRONT.XFE_E.SXN.t12 VSS.t296 VSS.t295 nfet_03v3 ad=3.52p pd=16.88u as=2.08p ps=8.52u w=8u l=0.28u
X99 VDD.t162 FE_O_N.t19 XRX.XCAP.ODD_D_BUF.t6 VDD.t161 pfet_03v3 ad=2.08p pd=8.52u as=2.08p ps=8.52u w=8u l=0.28u
X100 XRX.XFRONT.XFE_E.BN.t1 XRX.XFRONT.XFE_E.SXN.t20 VDD.t441 VDD.t440 pfet_03v3 ad=3.52p pd=16.88u as=2.08p ps=8.52u w=8u l=0.28u
X101 XRX.XCAP.O_QBI.t6 XRX.XCAP.ODD_D_BUF.t16 XRX.XCAP.O_PRST_TAIL.t9 VDD.t78 pfet_03v3 ad=3.52p pd=16.88u as=2.08p ps=8.52u w=8u l=0.28u
X102 a_n7300_n14500.t0 TERM_EN5_N.t1 a_n6400_n14452.t2 VDD.t127 pfet_03v3 ad=4.4p pd=20.88u as=2.6p ps=10.52u w=10u l=0.28u
X103 XRX.XFRONT.XFE_E.XN.t20 E_REGEN_CLK.t32 VDD.t255 VDD.t21 pfet_03v3 ad=2.08p pd=8.52u as=2.08p ps=8.52u w=8u l=0.28u
X104 XRX.XCAP.O_RST_TAIL.t3 O_CAPTURE_CLK.t4 VSS.t56 VSS.t19 nfet_03v3 ad=2.08p pd=8.52u as=2.08p ps=8.52u w=8u l=0.28u
X105 VSS.t401 XRX.XFRONT.XFE_O.BP.t11 FE_O_P.t9 VSS.t400 nfet_03v3 ad=2.08p pd=8.52u as=2.08p ps=8.52u w=8u l=0.28u
X106 VSS.t75 CLK_REST_BIAS.t7 a_65148_38800.t0 VSS.t71 nfet_03v3 ad=3.12p pd=12.52u as=5.28p ps=24.88u w=12u l=0.28u
X107 a_10548_44200.t3 PI_CLK_N.t3 a_11748_41600.t3 VSS.t137 nfet_03v3 ad=3.52p pd=16.88u as=2.08p ps=8.52u w=8u l=0.28u
X108 VDD.t13 XRX.XCAP.E_QBI.t19 XRX.XCAP.E_QBUF.t1 VDD.t12 pfet_03v3 ad=2.08p pd=8.52u as=3.52p ps=16.88u w=8u l=0.28u
X109 FE_E_N.t11 XRX.XFRONT.XFE_E.BP.t14 VSS.t447 VSS.t446 nfet_03v3 ad=2.08p pd=8.52u as=2.08p ps=8.52u w=8u l=0.28u
X110 XRX.XFRONT.XFE_E.NTAIL.t1 E_SENSE_CLK.t0 VSS.t84 VSS.t83 nfet_03v3 ad=3.52p pd=16.88u as=2.08p ps=8.52u w=8u l=0.28u
X111 VDD.t423 XRX.XFRONT.XFE_E.XN.t49 XRX.XFRONT.XFE_E.SXN.t9 VDD.t422 pfet_03v3 ad=2.08p pd=8.52u as=3.52p ps=16.88u w=8u l=0.28u
X112 XRX.XFRONT.XFE_O.NREGEN.t20 O_REGEN_CLK.t10 VDD.t556 VDD.t555 pfet_03v3 ad=3.52p pd=16.88u as=2.08p ps=8.52u w=8u l=0.28u
X113 XRX.XFRONT.XFE_E.XP.t3 XRX.XFRONT.XFE_E.SB.t13 XRX.XFRONT.XFE_E.NREGEN.t8 VSS.t195 nfet_03v3 ad=2.08p pd=8.52u as=2.08p ps=8.52u w=8u l=0.28u
X114 VDD.t546 O_REGEN_CLK.t15 XRX.XFRONT.XFE_O.XN.t21 VDD.t121 pfet_03v3 ad=2.08p pd=8.52u as=2.08p ps=8.52u w=8u l=0.28u
X115 XRX.XFRONT.XFE_O.XN.t0 XRX.XFRONT.XFE_O.SA.t13 XRX.XFRONT.XFE_O.NREGEN.t1 VSS.t29 nfet_03v3 ad=2.08p pd=8.52u as=2.08p ps=8.52u w=8u l=0.28u
X116 XRX.XFRONT.XFE_O.BP.t5 XRX.XFRONT.XFE_O.SXP.t16 VSS.t412 VSS.t411 nfet_03v3 ad=2.08p pd=8.52u as=2.08p ps=8.52u w=8u l=0.28u
X117 XRX.XFRONT.XFE_O.NREGEN.t0 XRX.XFRONT.XFE_O.SB.t8 XRX.XFRONT.XFE_O.XP.t0 VSS.t21 nfet_03v3 ad=2.08p pd=8.52u as=2.08p ps=8.52u w=8u l=0.28u
X118 a_n5052_n1000.t3 RX_BIAS.t8 VSS.t322 VSS.t316 nfet_03v3 ad=2.6p pd=10.52u as=2.6p ps=10.52u w=10u l=0.28u
X119 a_n10800_n12572.t0 TERM_EN6_N.t3 VDD.t192 VDD.t191 pfet_03v3 ad=0.88p pd=4.88u as=0.88p ps=4.88u w=2u l=0.28u
X120 XRX.XCAP.O_QI.t10 XRX.XCAP.O_QBI.t12 VSS.t306 VSS.t44 nfet_03v3 ad=3.52p pd=16.88u as=2.08p ps=8.52u w=8u l=0.28u
X121 VDD.t408 XRX.XFRONT.XFE_O.XN.t45 XRX.XFRONT.XFE_O.SXN.t10 VDD.t407 pfet_03v3 ad=2.08p pd=8.52u as=2.08p ps=8.52u w=8u l=0.28u
X122 XRX.XFRONT.XFE_E.VREGN.t11 E_REGEN_CLKB.t12 VDD.t212 VDD.t211 pfet_03v3 ad=2.08p pd=8.52u as=2.08p ps=8.52u w=8u l=0.28u
X123 XRX.XFRONT.XFE_E.XP.t31 XRX.XFRONT.XFE_E.XN.t56 XRX.XFRONT.XFE_E.VREGP.t9 VDD.t399 pfet_03v3 ad=2.08p pd=8.52u as=2.08p ps=8.52u w=8u l=0.28u
X124 XRX.XCAP.O_QBBUF.t3 XRX.XCAP.O_QI.t14 VSS.t486 VSS.t206 nfet_03v3 ad=1.76p pd=8.88u as=1.04p ps=4.52u w=4u l=0.28u
X125 XRX.XFRONT.XFE_O.NTAIL.t8 SAMP_O_P.t8 XRX.XFRONT.XFE_O.SA.t5 VSS.t389 nfet_03v3 ad=2.08p pd=8.52u as=3.52p ps=16.88u w=8u l=0.28u
X126 VDD.t190 XRX.XFRONT.XFE_E.BN.t23 FE_E_P.t9 VDD.t189 pfet_03v3 ad=2.08p pd=8.52u as=3.52p ps=16.88u w=8u l=0.28u
X127 a_n7300_n18100.t0 TERM_EN3_N.t1 a_n6400_n18052.t1 VDD.t6 pfet_03v3 ad=4.4p pd=20.88u as=2.6p ps=10.52u w=10u l=0.28u
X128 XRX.XFRONT.XFE_E.NREGEN.t2 XRX.XFRONT.XFE_E.SA.t14 XRX.XFRONT.XFE_E.XN.t1 VSS.t33 nfet_03v3 ad=2.08p pd=8.52u as=3.52p ps=16.88u w=8u l=0.28u
X129 VSS.t67 O_CAPTURE_CLK.t1 XRX.XCAP.O_RST_TAIL.t6 VSS.t66 nfet_03v3 ad=2.08p pd=8.52u as=2.08p ps=8.52u w=8u l=0.28u
X130 RX_RAWP.t1 RX_BW_EN_N.t1 a_484_3500.t1 VDD.t367 pfet_03v3 ad=2.2p pd=10.88u as=2.2p ps=10.88u w=5u l=0.28u
X131 a_n6400_n16252.t4 RXN.t7 VSS.t481 ppolyf_u r_width=1u r_length=1u
X132 XRX.XFRONT.XFE_O.BN.t4 XRX.XFRONT.XFE_O.SXN.t16 VSS.t364 VSS.t363 nfet_03v3 ad=2.08p pd=8.52u as=2.08p ps=8.52u w=8u l=0.28u
X133 XRX.XFRONT.XFE_E.SXP.t8 XRX.XFRONT.XFE_E.XP.t40 VSS.t219 VSS.t218 nfet_03v3 ad=2.08p pd=8.52u as=2.08p ps=8.52u w=8u l=0.28u
X134 XRX.XCAP.O_PRST_TAIL.t3 O_CAPTURE_CLKB.t12 VDD.t84 VDD.t58 pfet_03v3 ad=2.08p pd=8.52u as=2.08p ps=8.52u w=8u l=0.28u
X135 VDD.t224 E_REGEN_CLKB.t7 XRX.XFRONT.XFE_E.VREGP.t0 VDD.t223 pfet_03v3 ad=2.08p pd=8.52u as=3.52p ps=16.88u w=8u l=0.28u
X136 a_n6400_n23452.t0 a_n10800_n23372.t2 a_n7157_n23500.t1 VSS.t201 nfet_03v3 ad=2.6p pd=10.52u as=4.4p ps=20.88u w=10u l=0.28u
X137 VSS.t256 E_CAPTURE_CLK.t15 XRX.XCAP.E_SET_TAIL.t4 VSS.t255 nfet_03v3 ad=2.08p pd=8.52u as=3.52p ps=16.88u w=8u l=0.28u
X138 a_74148_31500.t4 PHASE_B_P.t1 a_72404_31500.t2 VSS.t94 nfet_03v3 ad=1.3p pd=5.52u as=2.2p ps=10.88u w=5u l=0.28u
X139 XRX.XFRONT.XFE_O.XN.t24 O_REGEN_CLK.t12 VDD.t554 VDD.t553 pfet_03v3 ad=3.52p pd=16.88u as=2.08p ps=8.52u w=8u l=0.28u
X140 XRX.XFRONT.XFE_O.NREGEN.t5 XRX.XFRONT.XFE_O.SA.t10 XRX.XFRONT.XFE_O.XN.t2 VSS.t138 nfet_03v3 ad=2.08p pd=8.52u as=2.08p ps=8.52u w=8u l=0.28u
X141 VDD.t286 XRX.XFRONT.XFE_O.BN.t19 FE_O_N.t9 VDD.t285 pfet_03v3 ad=2.08p pd=8.52u as=2.08p ps=8.52u w=8u l=0.28u
X142 ODD_QB.t5 XRX.XCAP.O_QBUF.t5 VSS.t523 VSS.t522 nfet_03v3 ad=2.08p pd=8.52u as=2.08p ps=8.52u w=8u l=0.28u
X143 XRX.XCAP.O_SET_TAIL.t7 O_CAPTURE_CLK.t8 VSS.t55 VSS.t54 nfet_03v3 ad=3.52p pd=16.88u as=2.08p ps=8.52u w=8u l=0.28u
X144 EVEN_Q.t0 XRX.XCAP.E_QBBUF.t7 VDD.t3 VDD.t2 pfet_03v3 ad=3.52p pd=16.88u as=2.08p ps=8.52u w=8u l=0.28u
X145 XRX.XCAP.E_QI.t5 XRX.XCAP.EVEN_DB_BUF.t18 XRX.XCAP.E_PSET_TAIL.t2 VDD.t71 pfet_03v3 ad=2.08p pd=8.52u as=2.08p ps=8.52u w=8u l=0.28u
X146 XRX.XFRONT.XFE_E.XP.t8 E_REGEN_CLK.t18 VDD.t242 VDD.t241 pfet_03v3 ad=2.08p pd=8.52u as=2.08p ps=8.52u w=8u l=0.28u
X147 VDD.t330 O_REGEN_CLKB.t11 XRX.XFRONT.XFE_O.VREGP.t4 VDD.t329 pfet_03v3 ad=2.08p pd=8.52u as=2.08p ps=8.52u w=8u l=0.28u
X148 XRX.XFRONT.XFE_O.XN.t25 O_REGEN_CLK.t27 XRX.XFRONT.XFE_O.XP.t15 VDD.t531 pfet_03v3 ad=2.08p pd=8.52u as=3.52p ps=16.88u w=8u l=0.28u
X149 RX_RAWN.t3 a_n3600_5641.t6 a_2148_n500.t7 VSS.t151 nfet_03v3 ad=2.2p pd=10.88u as=1.3p ps=5.52u w=5u l=0.28u
X150 XRX.XFRONT.XFE_O.SXN.t1 XRX.XFRONT.XFE_O.XN.t42 VDD.t75 VDD.t74 pfet_03v3 ad=3.52p pd=16.88u as=2.08p ps=8.52u w=8u l=0.28u
X151 VDD.t356 E_CAPTURE_CLKB.t11 XRX.XCAP.E_PRST_TAIL.t8 VDD.t303 pfet_03v3 ad=2.08p pd=8.52u as=2.08p ps=8.52u w=8u l=0.28u
X152 a_n1900_5958.t1 RX_BW_EN_N.t2 a_n3600_5641.t5 VDD.t366 pfet_03v3 ad=2.2p pd=10.88u as=2.2p ps=10.88u w=5u l=0.28u
X153 a_n6400_n12652.t2 TERM_EN6_N.t0 a_n7300_n12700.t1 VDD.t194 pfet_03v3 ad=2.6p pd=10.52u as=4.4p ps=20.88u w=10u l=0.28u
X154 XRX.XCAP.E_RST_TAIL.t0 XRX.XCAP.EVEN_DB_BUF.t15 XRX.XCAP.E_QI.t8 VSS.t28 nfet_03v3 ad=2.08p pd=8.52u as=3.52p ps=16.88u w=8u l=0.28u
X155 VDD.t51 VSS.t563 XRX.XFRONT.XFE_O.SB.t0 VDD.t50 pfet_03v3 ad=3.52p pd=16.88u as=3.52p ps=16.88u w=8u l=0.28u
X156 XRX.XFRONT.XFE_O.NREGEN.t33 XRX.XFRONT.XFE_O.XP.t37 XRX.XFRONT.XFE_O.XN.t34 VSS.t550 nfet_03v3 ad=2.08p pd=8.52u as=3.52p ps=16.88u w=8u l=0.28u
X157 XRX.XFRONT.XFE_E.XP.t1 XRX.XFRONT.XFE_E.SB.t7 XRX.XFRONT.XFE_E.NREGEN.t6 VSS.t100 nfet_03v3 ad=3.52p pd=16.88u as=2.08p ps=8.52u w=8u l=0.28u
X158 VSS.t356 XRX.XFRONT.XFE_O.SXN.t13 XRX.XFRONT.XFE_O.BN.t1 VSS.t355 nfet_03v3 ad=2.08p pd=8.52u as=2.08p ps=8.52u w=8u l=0.28u
X159 VDD.t565 FE_E_P.t25 XRX.XCAP.EVEN_DB_BUF.t0 VDD.t564 pfet_03v3 ad=2.08p pd=8.52u as=3.52p ps=16.88u w=8u l=0.28u
X160 XRX.XCAP.EVEN_DB_BUF.t7 FE_E_P.t18 VDD.t579 VDD.t578 pfet_03v3 ad=3.52p pd=16.88u as=2.08p ps=8.52u w=8u l=0.28u
X161 VDD.t22 E_SENSE_CLK.t7 XRX.XFRONT.XFE_E.SB.t0 VDD.t21 pfet_03v3 ad=2.08p pd=8.52u as=3.52p ps=16.88u w=8u l=0.28u
X162 VDD.t33 FE_O_P.t19 XRX.XCAP.ODD_DB_BUF.t6 VDD.t32 pfet_03v3 ad=2.08p pd=8.52u as=2.08p ps=8.52u w=8u l=0.28u
X163 SAMP_E_N.t1 RX_RESTP.t5 a_948_44200.t5 VSS.t177 nfet_03v3 ad=2.64p pd=12.88u as=1.56p ps=6.52u w=6u l=0.28u
X164 RXP.t4 a_n7300_n12700.t2 VSS.t32 ppolyf_u r_width=1u r_length=1u
X165 a_65148_38800.t4 a_66600_32348.t4 PI_CLK_N.t0 VSS.t111 nfet_03v3 ad=2.6p pd=10.52u as=4.4p ps=20.88u w=10u l=0.28u
X166 FE_O_N.t6 XRX.XFRONT.XFE_O.BN.t16 VDD.t280 VDD.t279 pfet_03v3 ad=3.52p pd=16.88u as=2.08p ps=8.52u w=8u l=0.28u
X167 XRX.XCAP.E_RST_TAIL.t7 E_CAPTURE_CLK.t4 VSS.t273 VSS.t85 nfet_03v3 ad=2.08p pd=8.52u as=2.08p ps=8.52u w=8u l=0.28u
X168 XRX.XFRONT.XFE_E.XP.t23 XRX.XFRONT.XFE_E.XN.t50 XRX.XFRONT.XFE_E.VREGP.t15 VDD.t292 pfet_03v3 ad=3.52p pd=16.88u as=2.08p ps=8.52u w=8u l=0.28u
X169 XRX.XFRONT.XFE_E.SXP.t0 XRX.XFRONT.XFE_E.XP.t44 VDD.t63 VDD.t62 pfet_03v3 ad=2.08p pd=8.52u as=2.08p ps=8.52u w=8u l=0.28u
X170 a_n6400_n19852.t0 RXN.t0 VSS.t0 ppolyf_u r_width=1u r_length=1u
X171 XRX.XFRONT.XFE_O.VREGP.t7 O_REGEN_CLKB.t8 VDD.t332 VDD.t331 pfet_03v3 ad=3.52p pd=16.88u as=2.08p ps=8.52u w=8u l=0.28u
X172 VSS.t377 XRX.XFRONT.XFE_E.SXP.t13 XRX.XFRONT.XFE_E.BP.t8 VSS.t376 nfet_03v3 ad=2.08p pd=8.52u as=2.08p ps=8.52u w=8u l=0.28u
X173 a_n6572_3500.t3 RX_BW_EN_N.t3 a_n6716_3500.t1 VDD.t365 pfet_03v3 ad=2.2p pd=10.88u as=2.2p ps=10.88u w=5u l=0.28u
X174 a_72548_31500.t3 PI_CTRL_A.t2 VSS.t115 VSS.t3 nfet_03v3 ad=1.3p pd=5.52u as=1.3p ps=5.52u w=5u l=0.28u
X175 SAMP_O_N.t4 SAMP_O_P.t5 a_12148_44200.t3 VSS.t392 nfet_03v3 ad=2.64p pd=12.88u as=1.56p ps=6.52u w=6u l=0.28u
X176 VDD.t204 XRX.XCAP.O_QBUF.t10 ODD_QB.t0 VDD.t203 pfet_03v3 ad=2.08p pd=8.52u as=3.52p ps=16.88u w=8u l=0.28u
X177 XRX.XFRONT.XFE_O.SB.t2 O_SENSE_CLK.t2 VDD.t122 VDD.t121 pfet_03v3 ad=3.52p pd=16.88u as=2.08p ps=8.52u w=8u l=0.28u
X178 VDD.t138 a_72404_31500.t4 VSS.t192 ppolyf_u r_width=2u r_length=4u
X179 VSS.t432 XRX.XFRONT.XFE_O.BN.t11 FE_O_N.t12 VSS.t431 nfet_03v3 ad=2.08p pd=8.52u as=2.08p ps=8.52u w=8u l=0.28u
X180 VDD.t456 XRX.XCAP.E_QI.t19 XRX.XCAP.E_QBBUF.t0 VDD.t455 pfet_03v3 ad=2.08p pd=8.52u as=3.52p ps=16.88u w=8u l=0.28u
X181 XRX.XFRONT.XFE_E.XN.t25 E_REGEN_CLK.t27 XRX.XFRONT.XFE_E.XP.t18 VDD.t261 pfet_03v3 ad=2.08p pd=8.52u as=3.52p ps=16.88u w=8u l=0.28u
X182 a_65148_29400.t5 PI_RAW_N.t4 a_66600_32348.t0 VSS.t111 nfet_03v3 ad=2.6p pd=10.52u as=4.4p ps=20.88u w=10u l=0.28u
X183 XRX.XFRONT.XFE_O.XN.t18 O_REGEN_CLK.t18 VDD.t542 VDD.t541 pfet_03v3 ad=2.08p pd=8.52u as=2.08p ps=8.52u w=8u l=0.28u
X184 XRX.XFRONT.XFE_O.XP.t3 XRX.XFRONT.XFE_O.SB.t11 XRX.XFRONT.XFE_O.NREGEN.t6 VSS.t164 nfet_03v3 ad=2.08p pd=8.52u as=2.08p ps=8.52u w=8u l=0.28u
X185 XRX.XCAP.O_SET_TAIL.t1 O_CAPTURE_CLK.t14 VSS.t41 VSS.t40 nfet_03v3 ad=2.08p pd=8.52u as=2.08p ps=8.52u w=8u l=0.28u
X186 VDD.t392 XRX.XFRONT.XFE_O.SXP.t21 XRX.XFRONT.XFE_O.BP.t0 VDD.t391 pfet_03v3 ad=2.08p pd=8.52u as=3.52p ps=16.88u w=8u l=0.28u
X187 VSS.t326 RX_BIAS.t2 a_2148_n500.t3 VSS.t311 nfet_03v3 ad=2.6p pd=10.52u as=2.6p ps=10.52u w=10u l=0.28u
X188 VDD.t168 SAMP_O_P.t2 VSS.t220 ppolyf_u r_width=2u r_length=5u
X189 XRX.XFRONT.XFE_O.NTAIL.t3 O_SENSE_BOOST.t4 VSS.t241 VSS.t240 nfet_03v3 ad=2.08p pd=8.52u as=2.08p ps=8.52u w=8u l=0.28u
X190 XRX.XFRONT.XFE_E.XP.t14 E_REGEN_CLK.t12 VDD.t272 VDD.t271 pfet_03v3 ad=3.52p pd=16.88u as=2.08p ps=8.52u w=8u l=0.28u
X191 FE_E_N.t5 XRX.XFRONT.XFE_E.BP.t22 VDD.t429 VDD.t428 pfet_03v3 ad=2.08p pd=8.52u as=2.08p ps=8.52u w=8u l=0.28u
X192 VSS.t79 CLK_REST_BIAS.t1 a_65148_29400.t2 VSS.t73 nfet_03v3 ad=3.12p pd=12.52u as=3.12p ps=12.52u w=12u l=0.28u
X193 VSS.t173 XRX.XFRONT.XFE_O.XN.t39 XRX.XFRONT.XFE_O.SXN.t4 VSS.t172 nfet_03v3 ad=2.08p pd=8.52u as=2.08p ps=8.52u w=8u l=0.28u
X194 XRX.XFRONT.XFE_O.SXN.t7 XRX.XFRONT.XFE_O.XN.t48 VDD.t396 VDD.t395 pfet_03v3 ad=2.08p pd=8.52u as=2.08p ps=8.52u w=8u l=0.28u
X195 VDD.t95 O_CAPTURE_CLKB.t9 XRX.XCAP.O_PRST_TAIL.t6 VDD.t94 pfet_03v3 ad=2.08p pd=8.52u as=2.08p ps=8.52u w=8u l=0.28u
X196 VSS.t263 E_CAPTURE_CLK.t1 XRX.XCAP.E_RST_TAIL.t10 VSS.t262 nfet_03v3 ad=2.08p pd=8.52u as=2.08p ps=8.52u w=8u l=0.28u
X197 XRX.XFRONT.XFE_E.VREGP.t12 XRX.XFRONT.XFE_E.XN.t53 XRX.XFRONT.XFE_E.XP.t26 VDD.t298 pfet_03v3 ad=2.08p pd=8.52u as=2.08p ps=8.52u w=8u l=0.28u
X198 XRX.XFRONT.XFE_E.NREGEN.t16 E_REGEN_CLK.t8 VDD.t278 VDD.t277 pfet_03v3 ad=3.52p pd=16.88u as=2.08p ps=8.52u w=8u l=0.28u
X199 a_n10800_n16172.t0 TERM_EN4_N.t3 VDD.t106 VDD.t105 pfet_03v3 ad=0.88p pd=4.88u as=0.88p ps=4.88u w=2u l=0.28u
X200 XRX.XFRONT.XFE_O.SB.t6 SAMP_O_N.t7 XRX.XFRONT.XFE_O.NTAIL.t10 VSS.t483 nfet_03v3 ad=3.52p pd=16.88u as=2.08p ps=8.52u w=8u l=0.28u
X201 XRX.XFRONT.XFE_E.NTAIL.t4 SAMP_E_N.t8 XRX.XFRONT.XFE_E.SA.t5 VSS.t147 nfet_03v3 ad=2.08p pd=8.52u as=3.52p ps=16.88u w=8u l=0.28u
X202 XRX.XFRONT.XFE_E.BP.t4 XRX.XFRONT.XFE_E.SXP.t16 VSS.t290 VSS.t289 nfet_03v3 ad=2.08p pd=8.52u as=2.08p ps=8.52u w=8u l=0.28u
X203 VDD.t431 XRX.XFRONT.XFE_E.BP.t17 FE_E_N.t6 VDD.t430 pfet_03v3 ad=2.08p pd=8.52u as=2.08p ps=8.52u w=8u l=0.28u
X204 a_n852_28800.t4 a_600_22678.t4 RX_RESTN.t1 VSS.t361 nfet_03v3 ad=2.6p pd=10.52u as=4.4p ps=20.88u w=10u l=0.28u
X205 VDD.t488 XRX.XFRONT.XFE_O.SXN.t21 XRX.XFRONT.XFE_O.BN.t9 VDD.t487 pfet_03v3 ad=2.08p pd=8.52u as=3.52p ps=16.88u w=8u l=0.28u
X206 VDD.t466 XRX.XCAP.E_QBBUF.t10 EVEN_Q.t5 VDD.t465 pfet_03v3 ad=2.08p pd=8.52u as=3.52p ps=16.88u w=8u l=0.28u
X207 XRX.XFRONT.XFE_E.XN.t18 E_REGEN_CLK.t34 VDD.t252 VDD.t251 pfet_03v3 ad=2.08p pd=8.52u as=2.08p ps=8.52u w=8u l=0.28u
X208 XRX.XFRONT.XFE_O.VREGP.t8 XRX.XFRONT.XFE_O.XN.t57 XRX.XFRONT.XFE_O.XP.t25 VDD.t296 pfet_03v3 ad=2.08p pd=8.52u as=3.52p ps=16.88u w=8u l=0.28u
X209 XRX.XCAP.E_PRST_TAIL.t11 E_CAPTURE_CLKB.t8 VDD.t358 VDD.t357 pfet_03v3 ad=3.52p pd=16.88u as=2.08p ps=8.52u w=8u l=0.28u
X210 VDD.t348 E_CAPTURE_CLKB.t15 XRX.XCAP.E_PRST_TAIL.t4 VDD.t347 pfet_03v3 ad=2.08p pd=8.52u as=3.52p ps=16.88u w=8u l=0.28u
X211 XRX.XCAP.O_QBBUF.t1 XRX.XCAP.O_QI.t18 VDD.t61 VDD.t60 pfet_03v3 ad=3.52p pd=16.88u as=2.08p ps=8.52u w=8u l=0.28u
X212 FE_O_N.t1 XRX.XFRONT.XFE_O.BN.t22 VDD.t112 VDD.t111 pfet_03v3 ad=2.08p pd=8.52u as=2.08p ps=8.52u w=8u l=0.28u
X213 XRX.XCAP.E_SET_TAIL.t11 E_CAPTURE_CLK.t8 VSS.t261 VSS.t260 nfet_03v3 ad=3.52p pd=16.88u as=2.08p ps=8.52u w=8u l=0.28u
X214 PI_RAW_P.t2 a_72404_31500.t5 a_80148_31500.t1 VSS.t102 nfet_03v3 ad=2.2p pd=10.88u as=1.3p ps=5.52u w=5u l=0.28u
X215 VSS.t45 O_CAPTURE_CLK.t11 XRX.XCAP.O_SET_TAIL.t4 VSS.t44 nfet_03v3 ad=2.08p pd=8.52u as=2.08p ps=8.52u w=8u l=0.28u
X216 VSS.t249 O_SENSE_BOOST.t1 XRX.XFRONT.XFE_O.NTAIL.t6 VSS.t248 nfet_03v3 ad=2.08p pd=8.52u as=2.08p ps=8.52u w=8u l=0.28u
X217 VSS.t438 XRX.XFRONT.XFE_E.BN.t11 FE_E_P.t11 VSS.t437 nfet_03v3 ad=2.08p pd=8.52u as=2.08p ps=8.52u w=8u l=0.28u
X218 XRX.XFRONT.XFE_E.VREGN.t13 E_REGEN_CLKB.t10 VDD.t222 VDD.t221 pfet_03v3 ad=2.08p pd=8.52u as=2.08p ps=8.52u w=8u l=0.28u
X219 VSS.t74 CLK_REST_BIAS.t5 a_65148_38800.t2 VSS.t73 nfet_03v3 ad=3.12p pd=12.52u as=3.12p ps=12.52u w=12u l=0.28u
X220 XRX.XFRONT.XFE_O.VREGP.t1 O_REGEN_CLKB.t14 VDD.t320 VDD.t319 pfet_03v3 ad=2.08p pd=8.52u as=2.08p ps=8.52u w=8u l=0.28u
X221 VDD.t270 E_REGEN_CLK.t15 XRX.XFRONT.XFE_E.XP.t11 VDD.t29 pfet_03v3 ad=2.08p pd=8.52u as=2.08p ps=8.52u w=8u l=0.28u
X222 XRX.XFRONT.XFE_E.XP.t6 XRX.XFRONT.XFE_E.XN.t35 XRX.XFRONT.XFE_E.NREGEN.t11 VSS.t308 nfet_03v3 ad=3.52p pd=16.88u as=2.08p ps=8.52u w=8u l=0.28u
X223 XRX.XCAP.EVEN_D_BUF.t5 FE_E_N.t20 VDD.t480 VDD.t479 pfet_03v3 ad=2.08p pd=8.52u as=2.08p ps=8.52u w=8u l=0.28u
X224 VDD.t571 FE_E_P.t21 XRX.XCAP.EVEN_DB_BUF.t4 VDD.t570 pfet_03v3 ad=2.08p pd=8.52u as=2.08p ps=8.52u w=8u l=0.28u
X225 a_n852_19400.t7 RX_RAWN.t5 a_600_22678.t1 VSS.t361 nfet_03v3 ad=2.6p pd=10.52u as=4.4p ps=20.88u w=10u l=0.28u
X226 XRX.XFRONT.XFE_E.VREGN.t0 XRX.XFRONT.XFE_E.XP.t57 XRX.XFRONT.XFE_E.XN.t8 VDD.t167 pfet_03v3 ad=2.08p pd=8.52u as=3.52p ps=16.88u w=8u l=0.28u
X227 VDD.t39 FE_O_P.t23 XRX.XCAP.ODD_DB_BUF.t2 VDD.t38 pfet_03v3 ad=2.08p pd=8.52u as=2.08p ps=8.52u w=8u l=0.28u
X228 VSS.t183 O_SENSE_CLK.t1 XRX.XFRONT.XFE_O.NTAIL.t0 VSS.t182 nfet_03v3 ad=2.08p pd=8.52u as=3.52p ps=16.88u w=8u l=0.28u
X229 VSS.t106 XRX.XFRONT.XFE_E.SXN.t17 XRX.XFRONT.XFE_E.BN.t4 VSS.t105 nfet_03v3 ad=2.08p pd=8.52u as=2.08p ps=8.52u w=8u l=0.28u
X230 XRX.XCAP.O_RST_TAIL.t11 XRX.XCAP.ODD_DB_BUF.t15 XRX.XCAP.O_QI.t6 VSS.t42 nfet_03v3 ad=2.08p pd=8.52u as=3.52p ps=16.88u w=8u l=0.28u
X231 VDD.t9 PI_RAW_N.t0 VSS.t27 ppolyf_u r_width=2u r_length=5.25u
X232 VSS.t533 O_REGEN_CLK.t5 XRX.XFRONT.XFE_O.NREGEN.t25 VSS.t240 nfet_03v3 ad=2.08p pd=8.52u as=2.08p ps=8.52u w=8u l=0.28u
X233 VDD.t516 O_REGEN_CLK.t35 XRX.XFRONT.XFE_O.XP.t7 VDD.t515 pfet_03v3 ad=2.08p pd=8.52u as=3.52p ps=16.88u w=8u l=0.28u
X234 a_n6400_n16252.t1 TERM_EN4_N.t0 a_n7300_n16300.t2 VDD.t108 pfet_03v3 ad=2.6p pd=10.52u as=4.4p ps=20.88u w=10u l=0.28u
X235 a_2548_44200.t3 PI_CLK_N.t5 a_2148_41600.t2 VSS.t135 nfet_03v3 ad=3.52p pd=16.88u as=2.08p ps=8.52u w=8u l=0.28u
X236 XRX.XCAP.O_QI.t4 XRX.XCAP.ODD_DB_BUF.t18 XRX.XCAP.O_PSET_TAIL.t0 VDD.t14 pfet_03v3 ad=2.08p pd=8.52u as=2.08p ps=8.52u w=8u l=0.28u
X237 VSS.t388 XRX.XCAP.E_QBUF.t6 EVEN_QB.t1 VSS.t387 nfet_03v3 ad=2.08p pd=8.52u as=3.52p ps=16.88u w=8u l=0.28u
X238 VDD.t102 O_CAPTURE_CLKB.t3 XRX.XCAP.O_PSET_TAIL.t8 VDD.t90 pfet_03v3 ad=2.08p pd=8.52u as=2.08p ps=8.52u w=8u l=0.28u
X239 a_n10800_n19772.t0 TERM_EN2_N.t3 VDD.t510 VDD.t509 pfet_03v3 ad=0.88p pd=4.88u as=0.88p ps=4.88u w=2u l=0.28u
X240 VDD.t81 XRX.XCAP.E_QBI.t17 XRX.XCAP.E_QI.t3 VDD.t71 pfet_03v3 ad=2.08p pd=8.52u as=3.52p ps=16.88u w=8u l=0.28u
X241 XRX.XFRONT.XFE_E.SXP.t6 XRX.XFRONT.XFE_E.XP.t38 VSS.t215 VSS.t214 nfet_03v3 ad=3.52p pd=16.88u as=2.08p ps=8.52u w=8u l=0.28u
X242 XRX.XCAP.E_QI.t7 XRX.XCAP.EVEN_DB_BUF.t16 XRX.XCAP.E_PSET_TAIL.t0 VDD.t0 pfet_03v3 ad=3.52p pd=16.88u as=2.08p ps=8.52u w=8u l=0.28u
X243 a_74148_31500.t1 PI_CTRL_B.t2 VSS.t4 VSS.t3 nfet_03v3 ad=1.3p pd=5.52u as=1.3p ps=5.52u w=5u l=0.28u
X244 FE_E_P.t0 XRX.XFRONT.XFE_E.BN.t14 VSS.t232 VSS.t231 nfet_03v3 ad=2.08p pd=8.52u as=2.08p ps=8.52u w=8u l=0.28u
X245 a_11748_41600.t5 SAMP_BIAS.t2 VSS.t509 VSS.t508 nfet_03v3 ad=2.6p pd=10.52u as=2.6p ps=10.52u w=10u l=0.28u
X246 RXP.t3 a_n7300_n16300.t0 VSS.t32 ppolyf_u r_width=1u r_length=1u
X247 XRX.XCAP.E_PSET_TAIL.t9 E_CAPTURE_CLKB.t2 VDD.t362 VDD.t353 pfet_03v3 ad=2.08p pd=8.52u as=2.08p ps=8.52u w=8u l=0.28u
X248 VSS.t560 FE_E_P.t15 XRX.XCAP.EVEN_DB_BUF.t10 VSS.t559 nfet_03v3 ad=2.08p pd=8.52u as=2.08p ps=8.52u w=8u l=0.28u
X249 XRX.XFRONT.XFE_E.XN.t24 E_REGEN_CLK.t28 VDD.t250 VDD.t249 pfet_03v3 ad=3.52p pd=16.88u as=2.08p ps=8.52u w=8u l=0.28u
X250 XRX.XFRONT.XFE_O.NREGEN.t22 O_REGEN_CLK.t8 VDD.t522 VDD.t521 pfet_03v3 ad=3.52p pd=16.88u as=2.08p ps=8.52u w=8u l=0.28u
X251 XRX.XCAP.O_QI.t1 XRX.XCAP.ODD_DB_BUF.t12 XRX.XCAP.O_RST_TAIL.t8 VSS.t48 nfet_03v3 ad=3.52p pd=16.88u as=2.08p ps=8.52u w=8u l=0.28u
X252 FE_O_N.t4 XRX.XFRONT.XFE_O.BN.t14 VSS.t350 VSS.t349 nfet_03v3 ad=2.08p pd=8.52u as=2.08p ps=8.52u w=8u l=0.28u
X253 XRX.XFRONT.XFE_O.NREGEN.t3 XRX.XFRONT.XFE_O.SA.t8 XRX.XFRONT.XFE_O.XN.t1 VSS.t117 nfet_03v3 ad=2.08p pd=8.52u as=2.08p ps=8.52u w=8u l=0.28u
X254 XRX.XFRONT.XFE_O.NREGEN.t28 O_REGEN_CLK.t2 VSS.t535 VSS.t248 nfet_03v3 ad=2.08p pd=8.52u as=2.08p ps=8.52u w=8u l=0.28u
X255 VDD.t86 O_CAPTURE_CLKB.t13 XRX.XCAP.O_PRST_TAIL.t2 VDD.t85 pfet_03v3 ad=2.08p pd=8.52u as=2.08p ps=8.52u w=8u l=0.28u
X256 XRX.XFRONT.XFE_O.NREGEN.t13 XRX.XFRONT.XFE_O.XN.t37 XRX.XFRONT.XFE_O.XP.t28 VSS.t305 nfet_03v3 ad=2.08p pd=8.52u as=3.52p ps=16.88u w=8u l=0.28u
X257 VSS.t399 XRX.XFRONT.XFE_O.BP.t15 FE_O_P.t5 VSS.t398 nfet_03v3 ad=2.08p pd=8.52u as=3.52p ps=16.88u w=8u l=0.28u
X258 a_n5052_2600.t5 RX_BIAS.t10 VSS.t320 VSS.t318 nfet_03v3 ad=0.88p pd=4.88u as=0.52p ps=2.52u w=2u l=0.28u
X259 a_n6572_3500.t2 RXP.t8 a_n5052_n1000.t7 VSS.t346 nfet_03v3 ad=4.4p pd=20.88u as=2.6p ps=10.52u w=10u l=0.28u
X260 a_n6400_n19852.t2 TERM_EN2_N.t0 a_n7300_n19900.t2 VDD.t512 pfet_03v3 ad=2.6p pd=10.52u as=4.4p ps=20.88u w=10u l=0.28u
X261 a_n3600_5641.t4 VTHN.t0 a_n5052_2600.t1 VSS.t250 nfet_03v3 ad=0.88p pd=4.88u as=0.52p ps=2.52u w=2u l=0.28u
X262 XRX.XFRONT.XFE_E.SB.t5 SAMP_E_P.t7 XRX.XFRONT.XFE_E.NTAIL.t2 VSS.t120 nfet_03v3 ad=3.52p pd=16.88u as=2.08p ps=8.52u w=8u l=0.28u
X263 XRX.XFRONT.XFE_O.NREGEN.t9 XRX.XFRONT.XFE_O.XP.t35 XRX.XFRONT.XFE_O.XN.t4 VSS.t212 nfet_03v3 ad=3.52p pd=16.88u as=2.08p ps=8.52u w=8u l=0.28u
X264 XRX.XFRONT.XFE_E.XP.t29 XRX.XFRONT.XFE_E.SB.t9 XRX.XFRONT.XFE_E.NREGEN.t30 VSS.t385 nfet_03v3 ad=2.08p pd=8.52u as=2.08p ps=8.52u w=8u l=0.28u
X265 XRX.XFRONT.XFE_E.SXP.t4 XRX.XFRONT.XFE_E.XP.t48 VDD.t145 VDD.t144 pfet_03v3 ad=2.08p pd=8.52u as=2.08p ps=8.52u w=8u l=0.28u
X266 XRX.XCAP.EVEN_D_BUF.t3 FE_E_N.t22 VDD.t477 VDD.t455 pfet_03v3 ad=2.08p pd=8.52u as=2.08p ps=8.52u w=8u l=0.28u
X267 VSS.t515 XRX.XCAP.O_QBBUF.t4 ODD_Q.t4 VSS.t514 nfet_03v3 ad=3.52p pd=16.88u as=2.08p ps=8.52u w=8u l=0.28u
X268 VDD.t178 XRX.XFRONT.XFE_E.SXP.t21 XRX.XFRONT.XFE_E.BP.t2 VDD.t177 pfet_03v3 ad=2.08p pd=8.52u as=3.52p ps=16.88u w=8u l=0.28u
X269 VDD.t256 E_REGEN_CLK.t31 XRX.XFRONT.XFE_E.XN.t21 VDD.t23 pfet_03v3 ad=2.08p pd=8.52u as=2.08p ps=8.52u w=8u l=0.28u
X270 a_n7157_n23500.t3 TERM_EN0_N.t1 a_n6400_n23452.t4 VDD.t371 pfet_03v3 ad=4.4p pd=20.88u as=2.6p ps=10.52u w=10u l=0.28u
X271 RXP.t1 a_n7300_n19900.t0 VSS.t32 ppolyf_u r_width=1u r_length=1u
X272 VSS.t475 E_SENSE_BOOST.t3 XRX.XFRONT.XFE_E.NTAIL.t8 VSS.t337 nfet_03v3 ad=2.08p pd=8.52u as=2.08p ps=8.52u w=8u l=0.28u
X273 XRX.XFRONT.XFE_E.SA.t1 E_SENSE_CLK.t2 VDD.t30 VDD.t29 pfet_03v3 ad=3.52p pd=16.88u as=2.08p ps=8.52u w=8u l=0.28u
X274 XRX.XFRONT.XFE_O.VREGN.t8 XRX.XFRONT.XFE_O.XP.t57 XRX.XFRONT.XFE_O.XN.t6 VDD.t444 pfet_03v3 ad=2.08p pd=8.52u as=3.52p ps=16.88u w=8u l=0.28u
X275 XRX.XFRONT.XFE_O.XP.t20 O_REGEN_CLK.t22 XRX.XFRONT.XFE_O.XN.t30 VDD.t534 pfet_03v3 ad=2.08p pd=8.52u as=2.08p ps=8.52u w=8u l=0.28u
X276 a_11748_41600.t2 PI_CLK_N.t4 a_10548_44200.t2 VSS.t136 nfet_03v3 ad=2.08p pd=8.52u as=3.52p ps=16.88u w=8u l=0.28u
X277 FE_O_P.t10 XRX.XFRONT.XFE_O.BP.t12 VSS.t403 VSS.t402 nfet_03v3 ad=2.08p pd=8.52u as=2.08p ps=8.52u w=8u l=0.28u
X278 VDD.t195 RX_RAWN.t0 VSS.t251 ppolyf_u r_width=2u r_length=3.43u
X279 VSS.t161 REST_BIAS.t3 a_n852_19400.t2 VSS.t152 nfet_03v3 ad=3.12p pd=12.52u as=5.28p ps=24.88u w=12u l=0.28u
X280 a_n7300_n14500.t4 a_n10800_n14372.t3 a_n6400_n14452.t4 VSS.t410 nfet_03v3 ad=4.4p pd=20.88u as=2.6p ps=10.52u w=10u l=0.28u
X281 VSS.t449 XRX.XFRONT.XFE_E.BP.t15 FE_E_N.t12 VSS.t448 nfet_03v3 ad=2.08p pd=8.52u as=3.52p ps=16.88u w=8u l=0.28u
X282 XRX.XCAP.O_PSET_TAIL.t11 O_CAPTURE_CLKB.t0 VDD.t104 VDD.t96 pfet_03v3 ad=3.52p pd=16.88u as=2.08p ps=8.52u w=8u l=0.28u
X283 VDD.t83 O_CAPTURE_CLKB.t7 XRX.XCAP.O_PSET_TAIL.t4 VDD.t82 pfet_03v3 ad=2.08p pd=8.52u as=3.52p ps=16.88u w=8u l=0.28u
X284 a_n10800_n12572.t1 TERM_EN6_N.t2 VSS.t237 VSS.t14 nfet_03v3 ad=0.44p pd=2.88u as=0.44p ps=2.88u w=1u l=0.28u
X285 XRX.XFRONT.XFE_O.XN.t20 O_REGEN_CLK.t16 VDD.t545 VDD.t123 pfet_03v3 ad=2.08p pd=8.52u as=2.08p ps=8.52u w=8u l=0.28u
X286 VDD.t548 O_REGEN_CLK.t11 XRX.XFRONT.XFE_O.NREGEN.t19 VDD.t547 pfet_03v3 ad=2.08p pd=8.52u as=3.52p ps=16.88u w=8u l=0.28u
X287 XRX.XFRONT.XFE_E.NREGEN.t31 XRX.XFRONT.XFE_E.SB.t12 XRX.XFRONT.XFE_E.XP.t30 VSS.t386 nfet_03v3 ad=2.08p pd=8.52u as=2.08p ps=8.52u w=8u l=0.28u
X288 XRX.XFRONT.XFE_E.BN.t7 XRX.XFRONT.XFE_E.SXN.t14 VSS.t300 VSS.t299 nfet_03v3 ad=2.08p pd=8.52u as=2.08p ps=8.52u w=8u l=0.28u
X289 VSS.t328 RX_BIAS.t0 a_2148_n500.t5 VSS.t311 nfet_03v3 ad=4.4p pd=20.88u as=2.6p ps=10.52u w=10u l=0.28u
X290 VDD.t160 FE_O_N.t21 XRX.XCAP.ODD_D_BUF.t4 VDD.t60 pfet_03v3 ad=2.08p pd=8.52u as=2.08p ps=8.52u w=8u l=0.28u
X291 a_n10800_n21572.t0 TERM_EN1_N.t3 VDD.t506 VDD.t505 pfet_03v3 ad=0.88p pd=4.88u as=0.88p ps=4.88u w=2u l=0.28u
X292 VSS.t187 XRX.XCAP.O_QBI.t13 XRX.XCAP.O_QI.t9 VSS.t46 nfet_03v3 ad=2.08p pd=8.52u as=3.52p ps=16.88u w=8u l=0.28u
X293 XRX.XFRONT.XFE_O.SXN.t11 XRX.XFRONT.XFE_O.XN.t46 VDD.t410 VDD.t409 pfet_03v3 ad=2.08p pd=8.52u as=2.08p ps=8.52u w=8u l=0.28u
X294 XRX.XCAP.E_QBBUF.t3 XRX.XCAP.E_QI.t14 VSS.t461 VSS.t460 nfet_03v3 ad=1.76p pd=8.88u as=1.04p ps=4.52u w=4u l=0.28u
X295 VDD.t220 E_REGEN_CLKB.t11 XRX.XFRONT.XFE_E.VREGN.t12 VDD.t219 pfet_03v3 ad=2.08p pd=8.52u as=2.08p ps=8.52u w=8u l=0.28u
X296 XRX.XFRONT.XFE_E.VREGP.t10 XRX.XFRONT.XFE_E.XN.t55 XRX.XFRONT.XFE_E.XP.t34 VDD.t412 pfet_03v3 ad=2.08p pd=8.52u as=2.08p ps=8.52u w=8u l=0.28u
X297 VSS.t319 RX_BIAS.t11 a_n5052_2600.t4 VSS.t318 nfet_03v3 ad=0.52p pd=2.52u as=0.52p ps=2.52u w=2u l=0.28u
X298 a_n5052_n1000.t8 RXP.t9 a_n6572_3500.t1 VSS.t346 nfet_03v3 ad=2.6p pd=10.52u as=4.4p ps=20.88u w=10u l=0.28u
X299 VSS.t487 XRX.XCAP.O_QI.t15 XRX.XCAP.O_QBBUF.t2 VSS.t204 nfet_03v3 ad=1.04p pd=4.52u as=1.76p ps=8.88u w=4u l=0.28u
X300 VSS.t25 XRX.XCAP.E_QBI.t13 XRX.XCAP.E_QI.t1 VSS.t24 nfet_03v3 ad=2.08p pd=8.52u as=3.52p ps=16.88u w=8u l=0.28u
X301 VSS.t153 REST_BIAS.t7 a_n852_28800.t0 VSS.t152 nfet_03v3 ad=3.12p pd=12.52u as=5.28p ps=24.88u w=12u l=0.28u
X302 XRX.XFRONT.XFE_E.BP.t6 XRX.XFRONT.XFE_E.SXP.t18 VSS.t294 VSS.t293 nfet_03v3 ad=2.08p pd=8.52u as=2.08p ps=8.52u w=8u l=0.28u
X303 XRX.XCAP.O_QBUF.t0 XRX.XCAP.O_QBI.t18 VDD.t17 VDD.t16 pfet_03v3 ad=3.52p pd=16.88u as=2.08p ps=8.52u w=8u l=0.28u
X304 FE_E_N.t2 XRX.XFRONT.XFE_E.BP.t12 VSS.t286 VSS.t285 nfet_03v3 ad=2.08p pd=8.52u as=2.08p ps=8.52u w=8u l=0.28u
X305 VDD.t316 O_REGEN_CLKB.t7 XRX.XFRONT.XFE_O.VREGN.t0 VDD.t315 pfet_03v3 ad=2.08p pd=8.52u as=3.52p ps=16.88u w=8u l=0.28u
X306 XRX.XFRONT.XFE_E.NREGEN.t20 E_REGEN_CLK.t4 VSS.t338 VSS.t337 nfet_03v3 ad=2.08p pd=8.52u as=2.08p ps=8.52u w=8u l=0.28u
X307 XRX.XCAP.E_SET_TAIL.t9 E_CAPTURE_CLK.t10 VSS.t265 VSS.t92 nfet_03v3 ad=2.08p pd=8.52u as=2.08p ps=8.52u w=8u l=0.28u
X308 XRX.XCAP.E_QBI.t6 XRX.XCAP.EVEN_D_BUF.t18 XRX.XCAP.E_PRST_TAIL.t2 VDD.t71 pfet_03v3 ad=2.08p pd=8.52u as=2.08p ps=8.52u w=8u l=0.28u
X309 VDD.t15 XRX.XCAP.O_QBI.t17 XRX.XCAP.O_QI.t0 VDD.t14 pfet_03v3 ad=2.08p pd=8.52u as=3.52p ps=16.88u w=8u l=0.28u
X310 VDD.t552 O_REGEN_CLK.t13 XRX.XFRONT.XFE_O.XN.t23 VDD.t551 pfet_03v3 ad=2.08p pd=8.52u as=2.08p ps=8.52u w=8u l=0.28u
X311 FE_O_N.t10 XRX.XFRONT.XFE_O.BN.t20 VDD.t288 VDD.t287 pfet_03v3 ad=2.08p pd=8.52u as=2.08p ps=8.52u w=8u l=0.28u
X312 XRX.XCAP.O_QBI.t1 XRX.XCAP.O_QI.t16 VDD.t469 VDD.t90 pfet_03v3 ad=3.52p pd=16.88u as=2.08p ps=8.52u w=8u l=0.28u
X313 XRX.XFRONT.XFE_O.XN.t13 XRX.XFRONT.XFE_O.SA.t11 XRX.XFRONT.XFE_O.NREGEN.t15 VSS.t455 nfet_03v3 ad=2.08p pd=8.52u as=2.08p ps=8.52u w=8u l=0.28u
X314 a_n7300_n18100.t4 a_n10800_n17972.t3 a_n6400_n18052.t4 VSS.t495 nfet_03v3 ad=4.4p pd=20.88u as=2.6p ps=10.52u w=10u l=0.28u
X315 VDD.t268 E_REGEN_CLK.t17 XRX.XFRONT.XFE_E.XP.t9 VDD.t267 pfet_03v3 ad=2.08p pd=8.52u as=2.08p ps=8.52u w=8u l=0.28u
X316 VSS.t501 SAMP_BIAS.t7 a_2148_41600.t4 VSS.t500 nfet_03v3 ad=2.6p pd=10.52u as=4.4p ps=20.88u w=10u l=0.28u
X317 VDD.t77 XRX.XFRONT.XFE_O.XN.t43 XRX.XFRONT.XFE_O.SXN.t2 VDD.t76 pfet_03v3 ad=2.08p pd=8.52u as=2.08p ps=8.52u w=8u l=0.28u
X318 a_75604_31500.t2 PHASE_B_N.t0 a_74148_31500.t6 VSS.t236 nfet_03v3 ad=2.2p pd=10.88u as=1.3p ps=5.52u w=5u l=0.28u
X319 VDD.t502 XRX.XCAP.O_QBUF.t8 ODD_QB.t4 VDD.t501 pfet_03v3 ad=2.08p pd=8.52u as=2.08p ps=8.52u w=8u l=0.28u
X320 XRX.XFRONT.XFE_E.VREGN.t9 E_REGEN_CLKB.t14 VDD.t208 VDD.t207 pfet_03v3 ad=2.08p pd=8.52u as=2.08p ps=8.52u w=8u l=0.28u
X321 VDD.t374 XRX.XFRONT.XFE_O.BP.t23 FE_O_P.t0 VDD.t373 pfet_03v3 ad=2.08p pd=8.52u as=3.52p ps=16.88u w=8u l=0.28u
X322 a_n6400_n21652.t4 TERM_EN1_N.t0 a_n7157_n21700.t4 VDD.t508 pfet_03v3 ad=2.6p pd=10.52u as=4.4p ps=20.88u w=10u l=0.28u
X323 a_n6400_n21652.t1 RXN.t4 VSS.t345 ppolyf_u r_width=1u r_length=2.43u
X324 VDD.t520 O_REGEN_CLK.t33 XRX.XFRONT.XFE_O.XP.t9 VDD.t519 pfet_03v3 ad=2.08p pd=8.52u as=2.08p ps=8.52u w=8u l=0.28u
X325 XRX.XFRONT.XFE_E.SB.t1 E_SENSE_CLK.t6 VDD.t24 VDD.t23 pfet_03v3 ad=3.52p pd=16.88u as=2.08p ps=8.52u w=8u l=0.28u
X326 a_948_44200.t4 RX_RESTP.t6 SAMP_E_N.t0 VSS.t176 nfet_03v3 ad=1.56p pd=6.52u as=2.64p ps=12.88u w=6u l=0.28u
X327 XRX.XFRONT.XFE_O.XP.t27 XRX.XFRONT.XFE_O.XN.t52 XRX.XFRONT.XFE_O.VREGP.t13 VDD.t419 pfet_03v3 ad=2.08p pd=8.52u as=2.08p ps=8.52u w=8u l=0.28u
X328 a_n6400_n12652.t3 a_n10800_n12572.t2 a_n7300_n12700.t3 VSS.t307 nfet_03v3 ad=2.6p pd=10.52u as=4.4p ps=20.88u w=10u l=0.28u
X329 VDD.t462 XRX.XCAP.E_QBUF.t8 EVEN_QB.t3 VDD.t461 pfet_03v3 ad=2.08p pd=8.52u as=2.08p ps=8.52u w=8u l=0.28u
X330 a_948_44200.t0 RX_RESTN.t6 SAMP_E_P.t1 VSS.t10 nfet_03v3 ad=1.56p pd=6.52u as=2.64p ps=12.88u w=6u l=0.28u
X331 VDD.t282 XRX.XFRONT.XFE_O.BN.t17 FE_O_N.t7 VDD.t281 pfet_03v3 ad=2.08p pd=8.52u as=2.08p ps=8.52u w=8u l=0.28u
X332 XRX.XFRONT.XFE_E.NTAIL.t11 E_SENSE_BOOST.t0 VSS.t480 VSS.t341 nfet_03v3 ad=3.52p pd=16.88u as=2.08p ps=8.52u w=8u l=0.28u
X333 VDD.t490 XRX.XFRONT.XFE_O.XP.t49 XRX.XFRONT.XFE_O.SXP.t7 VDD.t489 pfet_03v3 ad=2.08p pd=8.52u as=3.52p ps=16.88u w=8u l=0.28u
X334 VDD.t314 O_REGEN_CLKB.t9 XRX.XFRONT.XFE_O.VREGP.t6 VDD.t313 pfet_03v3 ad=2.08p pd=8.52u as=2.08p ps=8.52u w=8u l=0.28u
X335 XRX.XFRONT.XFE_O.XN.t27 O_REGEN_CLK.t25 XRX.XFRONT.XFE_O.XP.t17 VDD.t533 pfet_03v3 ad=2.08p pd=8.52u as=2.08p ps=8.52u w=8u l=0.28u
X336 EVEN_Q.t3 XRX.XCAP.E_QBBUF.t5 VSS.t457 VSS.t456 nfet_03v3 ad=2.08p pd=8.52u as=2.08p ps=8.52u w=8u l=0.28u
X337 a_2148_41600.t7 SAMP_BIAS.t4 VSS.t505 VSS.t504 nfet_03v3 ad=4.4p pd=20.88u as=2.6p ps=10.52u w=10u l=0.28u
X338 XRX.XFRONT.XFE_E.BP.t7 XRX.XFRONT.XFE_E.SXP.t12 VSS.t375 VSS.t374 nfet_03v3 ad=3.52p pd=16.88u as=2.08p ps=8.52u w=8u l=0.28u
X339 a_12148_44200.t2 SAMP_O_P.t6 SAMP_O_N.t3 VSS.t391 nfet_03v3 ad=1.56p pd=6.52u as=2.64p ps=12.88u w=6u l=0.28u
X340 FE_E_N.t0 XRX.XFRONT.XFE_E.BP.t10 VSS.t282 VSS.t281 nfet_03v3 ad=3.52p pd=16.88u as=2.08p ps=8.52u w=8u l=0.28u
X341 VDD.t124 O_SENSE_CLK.t3 XRX.XFRONT.XFE_O.SB.t1 VDD.t123 pfet_03v3 ad=2.08p pd=8.52u as=3.52p ps=16.88u w=8u l=0.28u
X342 XRX.XCAP.ODD_D_BUF.t7 FE_O_N.t18 VDD.t164 VDD.t163 pfet_03v3 ad=3.52p pd=16.88u as=2.08p ps=8.52u w=8u l=0.28u
X343 FE_O_N.t13 XRX.XFRONT.XFE_O.BN.t12 VSS.t434 VSS.t433 nfet_03v3 ad=2.08p pd=8.52u as=2.08p ps=8.52u w=8u l=0.28u
X344 VDD.t153 FE_O_N.t25 XRX.XCAP.ODD_D_BUF.t0 VDD.t152 pfet_03v3 ad=2.08p pd=8.52u as=3.52p ps=16.88u w=8u l=0.28u
X345 XRX.XFRONT.XFE_O.NREGEN.t30 O_REGEN_CLK.t0 VSS.t539 VSS.t538 nfet_03v3 ad=3.52p pd=16.88u as=2.08p ps=8.52u w=8u l=0.28u
X346 XRX.XFRONT.XFE_O.XP.t12 O_REGEN_CLK.t30 VDD.t526 VDD.t525 pfet_03v3 ad=2.08p pd=8.52u as=2.08p ps=8.52u w=8u l=0.28u
X347 VSS.t239 O_SENSE_BOOST.t5 XRX.XFRONT.XFE_O.NTAIL.t2 VSS.t238 nfet_03v3 ad=2.08p pd=8.52u as=3.52p ps=16.88u w=8u l=0.28u
X348 XRX.XFRONT.XFE_E.NREGEN.t33 XRX.XFRONT.XFE_E.SA.t8 XRX.XFRONT.XFE_E.XN.t34 VSS.t458 nfet_03v3 ad=2.08p pd=8.52u as=2.08p ps=8.52u w=8u l=0.28u
X349 XRX.XFRONT.XFE_O.SXN.t5 XRX.XFRONT.XFE_O.XN.t40 VSS.t175 VSS.t174 nfet_03v3 ad=2.08p pd=8.52u as=2.08p ps=8.52u w=8u l=0.28u
X350 a_n10800_n16172.t1 TERM_EN4_N.t2 VSS.t180 VSS.t14 nfet_03v3 ad=0.44p pd=2.88u as=0.44p ps=2.88u w=1u l=0.28u
X351 VSS.t203 FE_O_N.t17 XRX.XCAP.ODD_D_BUF.t8 VSS.t202 nfet_03v3 ad=2.08p pd=8.52u as=3.52p ps=16.88u w=8u l=0.28u
X352 VDD.t43 FE_O_P.t21 XRX.XCAP.ODD_DB_BUF.t4 VDD.t42 pfet_03v3 ad=2.08p pd=8.52u as=2.08p ps=8.52u w=8u l=0.28u
X353 XRX.XFRONT.XFE_E.XP.t25 XRX.XFRONT.XFE_E.XN.t52 XRX.XFRONT.XFE_E.VREGP.t13 VDD.t297 pfet_03v3 ad=2.08p pd=8.52u as=2.08p ps=8.52u w=8u l=0.28u
X354 SAMP_E_P.t2 SAMP_E_N.t5 a_2548_44200.t5 VSS.t150 nfet_03v3 ad=2.64p pd=12.88u as=1.56p ps=6.52u w=6u l=0.28u
X355 XRX.XFRONT.XFE_O.NTAIL.t11 SAMP_O_N.t8 XRX.XFRONT.XFE_O.SB.t5 VSS.t482 nfet_03v3 ad=2.08p pd=8.52u as=3.52p ps=16.88u w=8u l=0.28u
X356 VSS.t418 XRX.XFRONT.XFE_O.SXP.t19 XRX.XFRONT.XFE_O.BP.t2 VSS.t417 nfet_03v3 ad=2.08p pd=8.52u as=3.52p ps=16.88u w=8u l=0.28u
X357 XRX.XCAP.E_QBUF.t0 XRX.XCAP.E_QBI.t18 VDD.t11 VDD.t10 pfet_03v3 ad=3.52p pd=16.88u as=2.08p ps=8.52u w=8u l=0.28u
X358 XRX.XFRONT.XFE_E.SA.t6 SAMP_E_N.t7 XRX.XFRONT.XFE_E.NTAIL.t5 VSS.t148 nfet_03v3 ad=3.52p pd=16.88u as=2.08p ps=8.52u w=8u l=0.28u
X359 XRX.XCAP.ODD_DB_BUF.t11 FE_O_P.t14 VSS.t130 VSS.t129 nfet_03v3 ad=3.52p pd=16.88u as=2.08p ps=8.52u w=8u l=0.28u
X360 XRX.XCAP.O_QBI.t7 XRX.XCAP.ODD_D_BUF.t12 XRX.XCAP.O_SET_TAIL.t9 VSS.t62 nfet_03v3 ad=3.52p pd=16.88u as=2.08p ps=8.52u w=8u l=0.28u
X361 VSS.t288 XRX.XFRONT.XFE_E.SXP.t15 XRX.XFRONT.XFE_E.BP.t3 VSS.t287 nfet_03v3 ad=2.08p pd=8.52u as=2.08p ps=8.52u w=8u l=0.28u
X362 VDD.t254 E_REGEN_CLK.t33 XRX.XFRONT.XFE_E.XN.t19 VDD.t253 pfet_03v3 ad=2.08p pd=8.52u as=2.08p ps=8.52u w=8u l=0.28u
X363 VSS.t342 E_REGEN_CLK.t1 XRX.XFRONT.XFE_E.NREGEN.t23 VSS.t341 nfet_03v3 ad=2.08p pd=8.52u as=2.08p ps=8.52u w=8u l=0.28u
X364 VSS.t267 E_CAPTURE_CLK.t9 XRX.XCAP.E_SET_TAIL.t10 VSS.t266 nfet_03v3 ad=2.08p pd=8.52u as=2.08p ps=8.52u w=8u l=0.28u
X365 a_80148_31500.t0 a_72404_31500.t6 PI_RAW_P.t1 VSS.t101 nfet_03v3 ad=1.3p pd=5.52u as=2.2p ps=10.88u w=5u l=0.28u
X366 SAMP_O_P.t0 RX_RESTN.t3 a_10548_44200.t1 VSS.t13 nfet_03v3 ad=2.64p pd=12.88u as=1.56p ps=6.52u w=6u l=0.28u
X367 XRX.XCAP.O_SET_TAIL.t3 O_CAPTURE_CLK.t12 VSS.t47 VSS.t46 nfet_03v3 ad=2.08p pd=8.52u as=2.08p ps=8.52u w=8u l=0.28u
X368 XRX.XFRONT.XFE_E.SA.t4 VSS.t565 VDD.t55 VDD.t54 pfet_03v3 ad=3.52p pd=16.88u as=3.52p ps=16.88u w=8u l=0.28u
X369 XRX.XFRONT.XFE_O.VREGN.t10 XRX.XFRONT.XFE_O.XP.t55 XRX.XFRONT.XFE_O.XN.t7 VDD.t445 pfet_03v3 ad=2.08p pd=8.52u as=2.08p ps=8.52u w=8u l=0.28u
X370 FE_E_P.t6 XRX.XFRONT.XFE_E.BN.t20 VDD.t184 VDD.t183 pfet_03v3 ad=2.08p pd=8.52u as=2.08p ps=8.52u w=8u l=0.28u
X371 a_80148_31500.t5 PI_BUF_BIAS.t0 VSS.t140 VSS.t139 nfet_03v3 ad=4.4p pd=20.88u as=2.6p ps=10.52u w=10u l=0.28u
X372 XRX.XFRONT.XFE_O.NTAIL.t5 O_SENSE_BOOST.t2 VSS.t247 VSS.t246 nfet_03v3 ad=2.08p pd=8.52u as=2.08p ps=8.52u w=8u l=0.28u
X373 VSS.t370 XRX.XFRONT.XFE_O.SXN.t19 XRX.XFRONT.XFE_O.BN.t7 VSS.t369 nfet_03v3 ad=2.08p pd=8.52u as=3.52p ps=16.88u w=8u l=0.28u
X374 XRX.XFRONT.XFE_E.XN.t33 XRX.XFRONT.XFE_E.SA.t11 XRX.XFRONT.XFE_E.NREGEN.t32 VSS.t450 nfet_03v3 ad=2.08p pd=8.52u as=2.08p ps=8.52u w=8u l=0.28u
X375 XRX.XFRONT.XFE_E.XP.t12 E_REGEN_CLK.t14 VDD.t248 VDD.t247 pfet_03v3 ad=2.08p pd=8.52u as=2.08p ps=8.52u w=8u l=0.28u
X376 a_2148_n500.t6 a_n3600_5641.t7 RX_RAWN.t2 VSS.t151 nfet_03v3 ad=1.3p pd=5.52u as=2.2p ps=10.88u w=5u l=0.28u
X377 XRX.XCAP.ODD_D_BUF.t11 FE_O_N.t14 VSS.t209 VSS.t208 nfet_03v3 ad=3.52p pd=16.88u as=2.08p ps=8.52u w=8u l=0.28u
X378 XRX.XCAP.E_QBBUF.t1 XRX.XCAP.E_QI.t18 VDD.t308 VDD.t307 pfet_03v3 ad=3.52p pd=16.88u as=2.08p ps=8.52u w=8u l=0.28u
X379 XRX.XCAP.E_SET_TAIL.t7 E_CAPTURE_CLK.t12 VSS.t259 VSS.t24 nfet_03v3 ad=2.08p pd=8.52u as=2.08p ps=8.52u w=8u l=0.28u
X380 XRX.XCAP.E_PSET_TAIL.t5 E_CAPTURE_CLKB.t6 VDD.t359 VDD.t343 pfet_03v3 ad=2.08p pd=8.52u as=2.08p ps=8.52u w=8u l=0.28u
X381 VDD.t91 O_CAPTURE_CLKB.t11 XRX.XCAP.O_PRST_TAIL.t4 VDD.t90 pfet_03v3 ad=2.08p pd=8.52u as=2.08p ps=8.52u w=8u l=0.28u
X382 XRX.XCAP.O_QBI.t9 XRX.XCAP.ODD_D_BUF.t18 XRX.XCAP.O_PRST_TAIL.t11 VDD.t14 pfet_03v3 ad=2.08p pd=8.52u as=2.08p ps=8.52u w=8u l=0.28u
X383 a_n10800_n19772.t1 TERM_EN2_N.t2 VSS.t529 VSS.t14 nfet_03v3 ad=0.44p pd=2.88u as=0.44p ps=2.88u w=1u l=0.28u
X384 XRX.XFRONT.XFE_O.NREGEN.t24 O_REGEN_CLK.t6 VSS.t530 VSS.t238 nfet_03v3 ad=2.08p pd=8.52u as=2.08p ps=8.52u w=8u l=0.28u
X385 a_2148_41600.t3 PI_CLK_N.t6 a_2548_44200.t2 VSS.t134 nfet_03v3 ad=2.08p pd=8.52u as=3.52p ps=16.88u w=8u l=0.28u
X386 XRX.XCAP.E_QBI.t0 XRX.XCAP.EVEN_D_BUF.t16 XRX.XCAP.E_PRST_TAIL.t0 VDD.t0 pfet_03v3 ad=3.52p pd=16.88u as=2.08p ps=8.52u w=8u l=0.28u
X387 XRX.XFRONT.XFE_O.VREGP.t10 XRX.XFRONT.XFE_O.XN.t55 XRX.XFRONT.XFE_O.XP.t32 VDD.t291 pfet_03v3 ad=2.08p pd=8.52u as=2.08p ps=8.52u w=8u l=0.28u
X388 VDD.t149 XRX.XCAP.E_QBBUF.t8 EVEN_Q.t2 VDD.t148 pfet_03v3 ad=2.08p pd=8.52u as=2.08p ps=8.52u w=8u l=0.28u
X389 VSS.t53 O_CAPTURE_CLK.t9 XRX.XCAP.O_SET_TAIL.t6 VSS.t52 nfet_03v3 ad=2.08p pd=8.52u as=2.08p ps=8.52u w=8u l=0.28u
X390 XRX.XFRONT.XFE_O.XN.t12 XRX.XFRONT.XFE_O.XP.t52 XRX.XFRONT.XFE_O.VREGN.t13 VDD.t450 pfet_03v3 ad=2.08p pd=8.52u as=2.08p ps=8.52u w=8u l=0.28u
X391 XRX.XFRONT.XFE_E.XN.t31 E_REGEN_CLK.t21 XRX.XFRONT.XFE_E.XP.t16 VDD.t265 pfet_03v3 ad=2.08p pd=8.52u as=2.08p ps=8.52u w=8u l=0.28u
X392 XRX.XCAP.E_PRST_TAIL.t9 E_CAPTURE_CLKB.t10 VDD.t354 VDD.t353 pfet_03v3 ad=2.08p pd=8.52u as=2.08p ps=8.52u w=8u l=0.28u
X393 a_n6400_n16252.t3 a_n10800_n16172.t2 a_n7300_n16300.t4 VSS.t362 nfet_03v3 ad=2.6p pd=10.52u as=4.4p ps=20.88u w=10u l=0.28u
X394 XRX.XFRONT.XFE_O.VREGP.t3 O_REGEN_CLKB.t12 VDD.t328 VDD.t327 pfet_03v3 ad=2.08p pd=8.52u as=2.08p ps=8.52u w=8u l=0.28u
X395 XRX.XFRONT.XFE_E.XP.t28 XRX.XFRONT.XFE_E.XN.t37 XRX.XFRONT.XFE_E.NREGEN.t26 VSS.t381 nfet_03v3 ad=2.08p pd=8.52u as=3.52p ps=16.88u w=8u l=0.28u
X396 XRX.XCAP.EVEN_DB_BUF.t11 FE_E_P.t14 VSS.t562 VSS.t561 nfet_03v3 ad=3.52p pd=16.88u as=2.08p ps=8.52u w=8u l=0.28u
X397 VDD.t540 O_REGEN_CLK.t9 XRX.XFRONT.XFE_O.NREGEN.t21 VDD.t539 pfet_03v3 ad=2.08p pd=8.52u as=3.52p ps=16.88u w=8u l=0.28u
X398 XRX.XFRONT.XFE_E.NREGEN.t28 XRX.XFRONT.XFE_E.XP.t36 XRX.XFRONT.XFE_E.XN.t13 VSS.t383 nfet_03v3 ad=2.08p pd=8.52u as=2.08p ps=8.52u w=8u l=0.28u
X399 VSS.t110 XRX.XFRONT.XFE_E.SXN.t19 XRX.XFRONT.XFE_E.BN.t2 VSS.t109 nfet_03v3 ad=2.08p pd=8.52u as=3.52p ps=16.88u w=8u l=0.28u
X400 VDD.t472 FE_E_N.t25 XRX.XCAP.EVEN_D_BUF.t0 VDD.t471 pfet_03v3 ad=2.08p pd=8.52u as=3.52p ps=16.88u w=8u l=0.28u
X401 XRX.XCAP.EVEN_D_BUF.t7 FE_E_N.t18 VDD.t484 VDD.t483 pfet_03v3 ad=3.52p pd=16.88u as=2.08p ps=8.52u w=8u l=0.28u
X402 XRX.XCAP.O_RST_TAIL.t9 XRX.XCAP.ODD_DB_BUF.t13 XRX.XCAP.O_QI.t2 VSS.t44 nfet_03v3 ad=2.08p pd=8.52u as=2.08p ps=8.52u w=8u l=0.28u
X403 VSS.t352 XRX.XFRONT.XFE_O.BN.t15 FE_O_N.t5 VSS.t351 nfet_03v3 ad=2.08p pd=8.52u as=3.52p ps=16.88u w=8u l=0.28u
X404 VDD.t577 FE_E_P.t19 XRX.XCAP.EVEN_DB_BUF.t6 VDD.t576 pfet_03v3 ad=2.08p pd=8.52u as=2.08p ps=8.52u w=8u l=0.28u
X405 VSS.t536 O_REGEN_CLK.t3 XRX.XFRONT.XFE_O.NREGEN.t27 VSS.t246 nfet_03v3 ad=2.08p pd=8.52u as=2.08p ps=8.52u w=8u l=0.28u
X406 VDD.t37 FE_O_P.t25 XRX.XCAP.ODD_DB_BUF.t0 VDD.t36 pfet_03v3 ad=2.08p pd=8.52u as=3.52p ps=16.88u w=8u l=0.28u
X407 XRX.XCAP.ODD_DB_BUF.t7 FE_O_P.t18 VDD.t47 VDD.t46 pfet_03v3 ad=3.52p pd=16.88u as=2.08p ps=8.52u w=8u l=0.28u
X408 VSS.t527 XRX.XCAP.E_QBUF.t4 EVEN_QB.t5 VSS.t526 nfet_03v3 ad=3.52p pd=16.88u as=2.08p ps=8.52u w=8u l=0.28u
X409 VDD.t563 PI_CLK_N.t2 VSS.t488 ppolyf_u r_width=2u r_length=7.5u
X410 ODD_Q.t1 XRX.XCAP.O_QBBUF.t9 VDD.t458 VDD.t457 pfet_03v3 ad=2.08p pd=8.52u as=2.08p ps=8.52u w=8u l=0.28u
X411 VDD.t201 XRX.XFRONT.XFE_E.XN.t43 XRX.XFRONT.XFE_E.SXN.t1 VDD.t200 pfet_03v3 ad=2.08p pd=8.52u as=2.08p ps=8.52u w=8u l=0.28u
X412 RXP.t0 a_n7157_n21700.t0 VSS.t32 ppolyf_u r_width=1u r_length=2.43u
X413 XRX.XCAP.E_QBUF.t2 XRX.XCAP.E_QBI.t14 VSS.t224 VSS.t223 nfet_03v3 ad=1.76p pd=8.88u as=1.04p ps=4.52u w=4u l=0.28u
X414 XRX.XCAP.E_QBI.t2 XRX.XCAP.EVEN_D_BUF.t12 XRX.XCAP.E_SET_TAIL.t0 VSS.t36 nfet_03v3 ad=3.52p pd=16.88u as=2.08p ps=8.52u w=8u l=0.28u
X415 XRX.XFRONT.XFE_E.XP.t21 E_REGEN_CLK.t24 XRX.XFRONT.XFE_E.XN.t28 VDD.t25 pfet_03v3 ad=2.08p pd=8.52u as=2.08p ps=8.52u w=8u l=0.28u
X416 RXP.t7 RXN.t6 VSS.t470 ppolyf_u r_width=4u r_length=1.23u
X417 VDD.t143 XRX.XFRONT.XFE_E.XP.t47 XRX.XFRONT.XFE_E.SXP.t3 VDD.t142 pfet_03v3 ad=2.08p pd=8.52u as=2.08p ps=8.52u w=8u l=0.28u
X418 SAMP_O_N.t0 RX_RESTP.t3 a_10548_44200.t5 VSS.t179 nfet_03v3 ad=2.64p pd=12.88u as=1.56p ps=6.52u w=6u l=0.28u
X419 XRX.XFRONT.XFE_O.NREGEN.t14 XRX.XFRONT.XFE_O.SB.t14 XRX.XFRONT.XFE_O.XP.t5 VSS.t454 nfet_03v3 ad=2.08p pd=8.52u as=3.52p ps=16.88u w=8u l=0.28u
X420 VSS.t126 FE_O_P.t17 XRX.XCAP.ODD_DB_BUF.t8 VSS.t125 nfet_03v3 ad=2.08p pd=8.52u as=3.52p ps=16.88u w=8u l=0.28u
X421 XRX.XCAP.O_SET_TAIL.t8 XRX.XCAP.ODD_D_BUF.t15 XRX.XCAP.O_QBI.t5 VSS.t59 nfet_03v3 ad=2.08p pd=8.52u as=3.52p ps=16.88u w=8u l=0.28u
X422 ODD_Q.t0 XRX.XCAP.O_QBBUF.t5 VSS.t453 VSS.t452 nfet_03v3 ad=2.08p pd=8.52u as=2.08p ps=8.52u w=8u l=0.28u
X423 XRX.XFRONT.XFE_E.BP.t1 XRX.XFRONT.XFE_E.SXP.t20 VDD.t172 VDD.t171 pfet_03v3 ad=3.52p pd=16.88u as=2.08p ps=8.52u w=8u l=0.28u
X424 VSS.t556 FE_E_P.t17 XRX.XCAP.EVEN_DB_BUF.t8 VSS.t555 nfet_03v3 ad=2.08p pd=8.52u as=3.52p ps=16.88u w=8u l=0.28u
X425 XRX.XFRONT.XFE_E.XN.t22 E_REGEN_CLK.t30 VDD.t258 VDD.t257 pfet_03v3 ad=2.08p pd=8.52u as=2.08p ps=8.52u w=8u l=0.28u
X426 VDD.t470 a_66600_32348.t2 VSS.t488 ppolyf_u r_width=2u r_length=7.5u
X427 a_n6400_n19852.t4 a_n10800_n19772.t2 a_n7300_n19900.t4 VSS.t544 nfet_03v3 ad=2.6p pd=10.52u as=4.4p ps=20.88u w=10u l=0.28u
X428 XRX.XFRONT.XFE_E.NTAIL.t9 E_SENSE_BOOST.t2 VSS.t478 VSS.t329 nfet_03v3 ad=2.08p pd=8.52u as=2.08p ps=8.52u w=8u l=0.28u
X429 VDD.t452 XRX.XFRONT.XFE_O.XP.t47 XRX.XFRONT.XFE_O.SXP.t5 VDD.t451 pfet_03v3 ad=2.08p pd=8.52u as=2.08p ps=8.52u w=8u l=0.28u
X430 XRX.XFRONT.XFE_O.NREGEN.t11 XRX.XFRONT.XFE_O.XN.t35 XRX.XFRONT.XFE_O.XP.t30 VSS.t303 nfet_03v3 ad=3.52p pd=16.88u as=2.08p ps=8.52u w=8u l=0.28u
X431 VDD.t176 XRX.XFRONT.XFE_E.BN.t17 FE_E_P.t3 VDD.t175 pfet_03v3 ad=2.08p pd=8.52u as=2.08p ps=8.52u w=8u l=0.28u
X432 VSS.t142 PI_BUF_BIAS.t3 a_80148_31500.t2 VSS.t141 nfet_03v3 ad=2.6p pd=10.52u as=4.4p ps=20.88u w=10u l=0.28u
X433 VSS.t405 XRX.XFRONT.XFE_O.BP.t13 FE_O_P.t11 VSS.t404 nfet_03v3 ad=2.08p pd=8.52u as=2.08p ps=8.52u w=8u l=0.28u
X434 XRX.XCAP.O_PRST_TAIL.t7 O_CAPTURE_CLKB.t8 VDD.t97 VDD.t96 pfet_03v3 ad=3.52p pd=16.88u as=2.08p ps=8.52u w=8u l=0.28u
X435 VSS.t51 O_CAPTURE_CLK.t7 XRX.XCAP.O_RST_TAIL.t0 VSS.t50 nfet_03v3 ad=2.08p pd=8.52u as=3.52p ps=16.88u w=8u l=0.28u
X436 a_65148_29400.t1 CLK_REST_BIAS.t2 VSS.t70 VSS.t69 nfet_03v3 ad=3.12p pd=12.52u as=3.12p ps=12.52u w=12u l=0.28u
X437 VDD.t87 O_CAPTURE_CLKB.t15 XRX.XCAP.O_PRST_TAIL.t0 VDD.t82 pfet_03v3 ad=2.08p pd=8.52u as=3.52p ps=16.88u w=8u l=0.28u
X438 VDD.t234 E_REGEN_CLKB.t1 XRX.XFRONT.XFE_E.VREGP.t6 VDD.t233 pfet_03v3 ad=2.08p pd=8.52u as=2.08p ps=8.52u w=8u l=0.28u
X439 FE_O_P.t8 XRX.XFRONT.XFE_O.BP.t18 VDD.t388 VDD.t387 pfet_03v3 ad=2.08p pd=8.52u as=2.08p ps=8.52u w=8u l=0.28u
X440 XRX.XCAP.O_QBI.t3 XRX.XCAP.O_QI.t12 VSS.t18 VSS.t17 nfet_03v3 ad=3.52p pd=16.88u as=2.08p ps=8.52u w=8u l=0.28u
X441 XRX.XFRONT.XFE_E.SXN.t4 XRX.XFRONT.XFE_E.XN.t46 VDD.t402 VDD.t401 pfet_03v3 ad=2.08p pd=8.52u as=2.08p ps=8.52u w=8u l=0.28u
X442 a_n7157_n23500.t2 a_n10800_n23372.t3 a_n6400_n23452.t1 VSS.t227 nfet_03v3 ad=4.4p pd=20.88u as=2.6p ps=10.52u w=10u l=0.28u
X443 PI_CLK_P.t2 a_65000_32348.t3 a_65148_38800.t7 VSS.t394 nfet_03v3 ad=4.4p pd=20.88u as=2.6p ps=10.52u w=10u l=0.28u
X444 a_n10800_n21572.t1 TERM_EN1_N.t2 VSS.t528 VSS.t14 nfet_03v3 ad=0.44p pd=2.88u as=0.44p ps=2.88u w=1u l=0.28u
X445 VSS.t325 RX_BIAS.t5 a_n5052_n1000.t6 VSS.t311 nfet_03v3 ad=4.4p pd=20.88u as=2.6p ps=10.52u w=10u l=0.28u
X446 XRX.XCAP.EVEN_D_BUF.t9 FE_E_N.t16 VSS.t493 VSS.t462 nfet_03v3 ad=2.08p pd=8.52u as=2.08p ps=8.52u w=8u l=0.28u
X447 a_n7300_n12700.t0 TERM_EN6_N.t1 a_n6400_n12652.t1 VDD.t193 pfet_03v3 ad=4.4p pd=20.88u as=2.6p ps=10.52u w=10u l=0.28u
X448 XRX.XFRONT.XFE_E.XN.t9 XRX.XFRONT.XFE_E.XP.t54 XRX.XFRONT.XFE_E.VREGN.t3 VDD.t497 pfet_03v3 ad=2.08p pd=8.52u as=2.08p ps=8.52u w=8u l=0.28u
X449 a_n5052_n1000.t0 RXN.t9 a_n3600_5641.t1 VSS.t151 nfet_03v3 ad=2.6p pd=10.52u as=4.4p ps=20.88u w=10u l=0.28u
X450 VDD.t139 a_n1000_22678.t2 VSS.t132 ppolyf_u r_width=2u r_length=4.2u
X451 VSS.t476 E_SENSE_BOOST.t5 XRX.XFRONT.XFE_E.NTAIL.t6 VSS.t333 nfet_03v3 ad=2.08p pd=8.52u as=3.52p ps=16.88u w=8u l=0.28u
X452 XRX.XFRONT.XFE_O.SXP.t1 XRX.XFRONT.XFE_O.XP.t44 VDD.t132 VDD.t131 pfet_03v3 ad=2.08p pd=8.52u as=2.08p ps=8.52u w=8u l=0.28u
X453 VDD.t478 FE_E_N.t21 XRX.XCAP.EVEN_D_BUF.t4 VDD.t307 pfet_03v3 ad=2.08p pd=8.52u as=2.08p ps=8.52u w=8u l=0.28u
X454 XRX.XCAP.E_QI.t0 XRX.XCAP.E_QBI.t12 VSS.t23 VSS.t22 nfet_03v3 ad=3.52p pd=16.88u as=2.08p ps=8.52u w=8u l=0.28u
X455 XRX.XFRONT.XFE_O.XP.t22 O_REGEN_CLK.t20 XRX.XFRONT.XFE_O.XN.t32 VDD.t536 pfet_03v3 ad=3.52p pd=16.88u as=2.08p ps=8.52u w=8u l=0.28u
X456 FE_E_N.t9 XRX.XFRONT.XFE_E.BP.t20 VDD.t437 VDD.t436 pfet_03v3 ad=2.08p pd=8.52u as=2.08p ps=8.52u w=8u l=0.28u
X457 a_65000_32348.t2 PI_RAW_P.t3 a_65148_29400.t6 VSS.t394 nfet_03v3 ad=4.4p pd=20.88u as=2.6p ps=10.52u w=10u l=0.28u
X458 FE_O_P.t13 XRX.XFRONT.XFE_O.BP.t10 VSS.t409 VSS.t408 nfet_03v3 ad=3.52p pd=16.88u as=2.08p ps=8.52u w=8u l=0.28u
X459 XRX.XCAP.EVEN_DB_BUF.t3 FE_E_P.t22 VDD.t575 VDD.t574 pfet_03v3 ad=2.08p pd=8.52u as=2.08p ps=8.52u w=8u l=0.28u
X460 a_65148_38800.t1 CLK_REST_BIAS.t6 VSS.t76 VSS.t69 nfet_03v3 ad=3.12p pd=12.52u as=3.12p ps=12.52u w=12u l=0.28u
X461 VSS.t445 XRX.XFRONT.XFE_E.BP.t13 FE_E_N.t10 VSS.t361 nfet_03v3 ad=2.08p pd=8.52u as=2.08p ps=8.52u w=8u l=0.28u
X462 XRX.XFRONT.XFE_E.VREGP.t3 E_REGEN_CLKB.t4 VDD.t228 VDD.t227 pfet_03v3 ad=2.08p pd=8.52u as=2.08p ps=8.52u w=8u l=0.28u
X463 VSS.t330 E_REGEN_CLK.t3 XRX.XFRONT.XFE_E.NREGEN.t21 VSS.t329 nfet_03v3 ad=2.08p pd=8.52u as=2.08p ps=8.52u w=8u l=0.28u
X464 XRX.XFRONT.XFE_E.NREGEN.t10 XRX.XFRONT.XFE_E.SB.t14 XRX.XFRONT.XFE_E.XP.t5 VSS.t211 nfet_03v3 ad=2.08p pd=8.52u as=3.52p ps=16.88u w=8u l=0.28u
X465 ODD_Q.t5 XRX.XCAP.O_QBBUF.t7 VDD.t504 VDD.t503 pfet_03v3 ad=3.52p pd=16.88u as=2.08p ps=8.52u w=8u l=0.28u
X466 VDD.t274 E_REGEN_CLK.t11 XRX.XFRONT.XFE_E.NREGEN.t13 VDD.t273 pfet_03v3 ad=2.08p pd=8.52u as=3.52p ps=16.88u w=8u l=0.28u
X467 XRX.XCAP.O_PSET_TAIL.t3 XRX.XCAP.ODD_DB_BUF.t17 XRX.XCAP.O_QI.t8 VDD.t79 pfet_03v3 ad=2.08p pd=8.52u as=2.08p ps=8.52u w=8u l=0.28u
X468 XRX.XCAP.O_PSET_TAIL.t9 O_CAPTURE_CLKB.t2 VDD.t99 VDD.t92 pfet_03v3 ad=2.08p pd=8.52u as=2.08p ps=8.52u w=8u l=0.28u
X469 VDD.t53 VSS.t564 XRX.XFRONT.XFE_O.SA.t0 VDD.t52 pfet_03v3 ad=3.52p pd=16.88u as=3.52p ps=16.88u w=8u l=0.28u
X470 a_74148_31500.t7 PHASE_B_N.t1 a_75604_31500.t1 VSS.t235 nfet_03v3 ad=1.3p pd=5.52u as=2.2p ps=10.88u w=5u l=0.28u
X471 VDD.t210 E_REGEN_CLKB.t13 XRX.XFRONT.XFE_E.VREGN.t10 VDD.t209 pfet_03v3 ad=2.08p pd=8.52u as=2.08p ps=8.52u w=8u l=0.28u
X472 XRX.XFRONT.XFE_E.VREGP.t8 XRX.XFRONT.XFE_E.XN.t57 XRX.XFRONT.XFE_E.XP.t32 VDD.t400 pfet_03v3 ad=2.08p pd=8.52u as=3.52p ps=16.88u w=8u l=0.28u
X473 XRX.XFRONT.XFE_E.SB.t2 E_SENSE_CLK.t5 XRX.XFRONT.XFE_E.SA.t3 VDD.t25 pfet_03v3 ad=2.08p pd=8.52u as=3.52p ps=16.88u w=8u l=0.28u
X474 VDD.t48 RX_RESTP.t0 VSS.t132 ppolyf_u r_width=2u r_length=4.2u
X475 XRX.XCAP.E_PSET_TAIL.t3 XRX.XCAP.EVEN_DB_BUF.t19 XRX.XCAP.E_QI.t4 VDD.t72 pfet_03v3 ad=2.08p pd=8.52u as=3.52p ps=16.88u w=8u l=0.28u
X476 VDD.t151 FE_O_N.t23 XRX.XCAP.ODD_D_BUF.t2 VDD.t150 pfet_03v3 ad=2.08p pd=8.52u as=2.08p ps=8.52u w=8u l=0.28u
X477 XRX.XFRONT.XFE_O.BP.t7 XRX.XFRONT.XFE_O.SXP.t14 VSS.t424 VSS.t423 nfet_03v3 ad=2.08p pd=8.52u as=2.08p ps=8.52u w=8u l=0.28u
X478 XRX.XCAP.E_SET_TAIL.t3 XRX.XCAP.EVEN_D_BUF.t15 XRX.XCAP.E_QBI.t5 VSS.t86 nfet_03v3 ad=2.08p pd=8.52u as=3.52p ps=16.88u w=8u l=0.28u
X479 a_12148_44200.t1 PI_CLK_P.t3 a_11748_41600.t0 VSS.t99 nfet_03v3 ad=3.52p pd=16.88u as=2.08p ps=8.52u w=8u l=0.28u
X480 VSS.t543 XRX.XFRONT.XFE_E.XP.t41 XRX.XFRONT.XFE_E.SXP.t9 VSS.t542 nfet_03v3 ad=2.08p pd=8.52u as=3.52p ps=16.88u w=8u l=0.28u
X481 a_n6400_n14452.t0 RXN.t2 VSS.t118 ppolyf_u r_width=1u r_length=1u
X482 VDD.t334 O_REGEN_CLKB.t5 XRX.XFRONT.XFE_O.VREGN.t2 VDD.t333 pfet_03v3 ad=2.08p pd=8.52u as=2.08p ps=8.52u w=8u l=0.28u
X483 XRX.XFRONT.XFE_O.VREGP.t12 XRX.XFRONT.XFE_O.XN.t53 XRX.XFRONT.XFE_O.XP.t26 VDD.t289 pfet_03v3 ad=2.08p pd=8.52u as=2.08p ps=8.52u w=8u l=0.28u
X484 XRX.XFRONT.XFE_E.NREGEN.t18 E_REGEN_CLK.t6 VSS.t334 VSS.t333 nfet_03v3 ad=2.08p pd=8.52u as=2.08p ps=8.52u w=8u l=0.28u
X485 VSS.t269 E_CAPTURE_CLK.t7 XRX.XCAP.E_RST_TAIL.t4 VSS.t268 nfet_03v3 ad=2.08p pd=8.52u as=3.52p ps=16.88u w=8u l=0.28u
X486 a_n6400_n21652.t0 a_n10800_n21572.t2 a_n7157_n21700.t1 VSS.t193 nfet_03v3 ad=2.6p pd=10.52u as=4.4p ps=20.88u w=10u l=0.28u
X487 VSS.t199 XRX.XFRONT.XFE_O.XP.t41 XRX.XFRONT.XFE_O.SXP.t3 VSS.t198 nfet_03v3 ad=2.08p pd=8.52u as=3.52p ps=16.88u w=8u l=0.28u
X488 VDD.t246 E_REGEN_CLK.t19 XRX.XFRONT.XFE_E.XP.t7 VDD.t245 pfet_03v3 ad=2.08p pd=8.52u as=3.52p ps=16.88u w=8u l=0.28u
X489 VDD.t69 a_n6572_3500.t0 VSS.t166 ppolyf_u r_width=2u r_length=4.57u
X490 VSS.t468 XRX.XCAP.E_QBBUF.t4 EVEN_Q.t4 VSS.t467 nfet_03v3 ad=3.52p pd=16.88u as=2.08p ps=8.52u w=8u l=0.28u
X491 XRX.XCAP.E_QBI.t11 XRX.XCAP.E_QI.t12 VSS.t451 VSS.t37 nfet_03v3 ad=3.52p pd=16.88u as=2.08p ps=8.52u w=8u l=0.28u
X492 XRX.XFRONT.XFE_O.XP.t16 O_REGEN_CLK.t26 XRX.XFRONT.XFE_O.XN.t26 VDD.t532 pfet_03v3 ad=2.08p pd=8.52u as=2.08p ps=8.52u w=8u l=0.28u
X493 VSS.t503 SAMP_BIAS.t5 a_2148_41600.t6 VSS.t502 nfet_03v3 ad=2.6p pd=10.52u as=2.6p ps=10.52u w=10u l=0.28u
X494 XRX.XCAP.E_QI.t11 XRX.XCAP.EVEN_DB_BUF.t12 XRX.XCAP.E_RST_TAIL.t1 VSS.t92 nfet_03v3 ad=3.52p pd=16.88u as=2.08p ps=8.52u w=8u l=0.28u
X495 XRX.XFRONT.XFE_E.SXN.t2 XRX.XFRONT.XFE_E.XN.t40 VSS.t277 VSS.t276 nfet_03v3 ad=2.08p pd=8.52u as=2.08p ps=8.52u w=8u l=0.28u
X496 VDD.t380 XRX.XFRONT.XFE_O.BP.t21 FE_O_P.t3 VDD.t379 pfet_03v3 ad=2.08p pd=8.52u as=2.08p ps=8.52u w=8u l=0.28u
X497 VDD.t467 a_5300_5958.t1 VSS.t471 ppolyf_u r_width=1u r_length=1.4u
X498 VSS.t162 REST_BIAS.t1 a_n852_19400.t4 VSS.t156 nfet_03v3 ad=3.12p pd=12.52u as=3.12p ps=12.52u w=12u l=0.28u
X499 VDD.t137 SAMP_E_N.t2 VSS.t191 ppolyf_u r_width=2u r_length=5u
X500 a_72404_31500.t1 PHASE_A_P.t0 a_72548_31500.t0 VSS.t31 nfet_03v3 ad=2.2p pd=10.88u as=1.3p ps=5.52u w=5u l=0.28u
X501 XRX.XFRONT.XFE_O.XN.t5 XRX.XFRONT.XFE_O.XP.t36 XRX.XFRONT.XFE_O.NREGEN.t10 VSS.t213 nfet_03v3 ad=2.08p pd=8.52u as=2.08p ps=8.52u w=8u l=0.28u
X502 VDD.t523 O_REGEN_CLK.t31 XRX.XFRONT.XFE_O.XP.t11 VDD.t117 pfet_03v3 ad=2.08p pd=8.52u as=2.08p ps=8.52u w=8u l=0.28u
X503 ODD_QB.t2 XRX.XCAP.O_QBUF.t9 VDD.t500 VDD.t499 pfet_03v3 ad=2.08p pd=8.52u as=2.08p ps=8.52u w=8u l=0.28u
X504 XRX.XFRONT.XFE_O.VREGN.t5 O_REGEN_CLKB.t2 VDD.t326 VDD.t325 pfet_03v3 ad=2.08p pd=8.52u as=2.08p ps=8.52u w=8u l=0.28u
X505 XRX.XFRONT.XFE_O.XP.t23 XRX.XFRONT.XFE_O.XN.t50 XRX.XFRONT.XFE_O.VREGP.t15 VDD.t417 pfet_03v3 ad=3.52p pd=16.88u as=2.08p ps=8.52u w=8u l=0.28u
X506 XRX.XFRONT.XFE_E.VREGN.t6 XRX.XFRONT.XFE_E.XP.t51 XRX.XFRONT.XFE_E.XN.t6 VDD.t134 pfet_03v3 ad=2.08p pd=8.52u as=2.08p ps=8.52u w=8u l=0.28u
X507 a_n852_28800.t6 a_n1000_22678.t4 RX_RESTP.t1 VSS.t87 nfet_03v3 ad=2.6p pd=10.52u as=4.4p ps=20.88u w=10u l=0.28u
X508 XRX.XCAP.E_PSET_TAIL.t7 E_CAPTURE_CLKB.t4 VDD.t360 VDD.t305 pfet_03v3 ad=2.08p pd=8.52u as=2.08p ps=8.52u w=8u l=0.28u
X509 a_2548_44200.t4 SAMP_E_N.t6 SAMP_E_P.t3 VSS.t149 nfet_03v3 ad=1.56p pd=6.52u as=2.64p ps=12.88u w=6u l=0.28u
X510 XRX.XFRONT.XFE_O.SXP.t10 XRX.XFRONT.XFE_O.XP.t38 VSS.t552 VSS.t551 nfet_03v3 ad=3.52p pd=16.88u as=2.08p ps=8.52u w=8u l=0.28u
X511 VDD.t300 XRX.XCAP.E_QBUF.t10 EVEN_QB.t0 VDD.t299 pfet_03v3 ad=2.08p pd=8.52u as=3.52p ps=16.88u w=8u l=0.28u
X512 VSS.t124 FE_O_P.t15 XRX.XCAP.ODD_DB_BUF.t10 VSS.t123 nfet_03v3 ad=2.08p pd=8.52u as=2.08p ps=8.52u w=8u l=0.28u
X513 XRX.XFRONT.XFE_O.XN.t29 O_REGEN_CLK.t23 XRX.XFRONT.XFE_O.XP.t19 VDD.t120 pfet_03v3 ad=2.08p pd=8.52u as=2.08p ps=8.52u w=8u l=0.28u
X514 a_n7300_n16300.t1 TERM_EN4_N.t1 a_n6400_n16252.t0 VDD.t107 pfet_03v3 ad=4.4p pd=20.88u as=2.6p ps=10.52u w=10u l=0.28u
X515 XRX.XFRONT.XFE_E.BP.t9 XRX.XFRONT.XFE_E.SXP.t14 VSS.t379 VSS.t378 nfet_03v3 ad=2.08p pd=8.52u as=2.08p ps=8.52u w=8u l=0.28u
X516 XRX.XCAP.O_SET_TAIL.t10 XRX.XCAP.ODD_D_BUF.t13 XRX.XCAP.O_QBI.t10 VSS.t17 nfet_03v3 ad=2.08p pd=8.52u as=2.08p ps=8.52u w=8u l=0.28u
X517 VSS.t157 REST_BIAS.t5 a_n852_28800.t2 VSS.t156 nfet_03v3 ad=3.12p pd=12.52u as=3.12p ps=12.52u w=12u l=0.28u
X518 FE_O_N.t11 XRX.XFRONT.XFE_O.BN.t10 VSS.t430 VSS.t429 nfet_03v3 ad=3.52p pd=16.88u as=2.08p ps=8.52u w=8u l=0.28u
X519 XRX.XFRONT.XFE_E.NREGEN.t24 E_REGEN_CLK.t0 VSS.t344 VSS.t343 nfet_03v3 ad=3.52p pd=16.88u as=2.08p ps=8.52u w=8u l=0.28u
X520 a_10548_44200.t0 RX_RESTN.t4 SAMP_O_P.t1 VSS.t12 nfet_03v3 ad=1.56p pd=6.52u as=2.64p ps=12.88u w=6u l=0.28u
X521 XRX.XFRONT.XFE_O.XP.t14 O_REGEN_CLK.t28 VDD.t530 VDD.t529 pfet_03v3 ad=3.52p pd=16.88u as=2.08p ps=8.52u w=8u l=0.28u
X522 a_n852_19400.t1 RX_RAWP.t5 a_n1000_22678.t0 VSS.t87 nfet_03v3 ad=2.6p pd=10.52u as=4.4p ps=20.88u w=10u l=0.28u
X523 VSS.t146 PI_BUF_BIAS.t1 a_80148_31500.t4 VSS.t145 nfet_03v3 ad=2.6p pd=10.52u as=2.6p ps=10.52u w=10u l=0.28u
X524 VSS.t245 O_SENSE_BOOST.t3 XRX.XFRONT.XFE_O.NTAIL.t4 VSS.t244 nfet_03v3 ad=2.08p pd=8.52u as=2.08p ps=8.52u w=8u l=0.28u
X525 XRX.XFRONT.XFE_E.NREGEN.t0 XRX.XFRONT.XFE_E.SA.t10 XRX.XFRONT.XFE_E.XN.t0 VSS.t9 nfet_03v3 ad=2.08p pd=8.52u as=2.08p ps=8.52u w=8u l=0.28u
X526 XRX.XCAP.ODD_D_BUF.t5 FE_O_N.t20 VDD.t159 VDD.t158 pfet_03v3 ad=2.08p pd=8.52u as=2.08p ps=8.52u w=8u l=0.28u
X527 VDD.t425 XRX.XFRONT.XFE_E.BP.t23 FE_E_N.t3 VDD.t424 pfet_03v3 ad=2.08p pd=8.52u as=3.52p ps=16.88u w=8u l=0.28u
X528 VSS.t207 FE_O_N.t15 XRX.XCAP.ODD_D_BUF.t10 VSS.t206 nfet_03v3 ad=2.08p pd=8.52u as=2.08p ps=8.52u w=8u l=0.28u
X529 a_72548_31500.t5 PI_CTRL_A.t0 VSS.t116 VSS.t7 nfet_03v3 ad=2.2p pd=10.88u as=1.3p ps=5.52u w=5u l=0.28u
X530 a_948_44200.t3 PI_CLK_P.t5 a_2148_41600.t0 VSS.t97 nfet_03v3 ad=3.52p pd=16.88u as=2.08p ps=8.52u w=8u l=0.28u
X531 XRX.XCAP.E_PRST_TAIL.t5 E_CAPTURE_CLKB.t14 VDD.t344 VDD.t343 pfet_03v3 ad=2.08p pd=8.52u as=2.08p ps=8.52u w=8u l=0.28u
X532 XRX.XFRONT.XFE_E.SXN.t8 XRX.XFRONT.XFE_E.XN.t48 VDD.t421 VDD.t420 pfet_03v3 ad=2.08p pd=8.52u as=2.08p ps=8.52u w=8u l=0.28u
X533 PI_RAW_N.t2 a_75604_31500.t5 a_80148_31500.t7 VSS.t443 nfet_03v3 ad=2.2p pd=10.88u as=1.3p ps=5.52u w=5u l=0.28u
X534 VSS.t264 E_CAPTURE_CLK.t11 XRX.XCAP.E_SET_TAIL.t8 VSS.t22 nfet_03v3 ad=2.08p pd=8.52u as=2.08p ps=8.52u w=8u l=0.28u
X535 a_n10800_n14372.t0 TERM_EN5_N.t3 VDD.t126 VDD.t125 pfet_03v3 ad=0.88p pd=4.88u as=0.88p ps=4.88u w=2u l=0.28u
X536 XRX.XFRONT.XFE_O.NREGEN.t18 XRX.XFRONT.XFE_O.SA.t14 XRX.XFRONT.XFE_O.XN.t15 VSS.t496 nfet_03v3 ad=2.08p pd=8.52u as=3.52p ps=16.88u w=8u l=0.28u
X537 VSS.t414 XRX.XFRONT.XFE_O.SXP.t17 XRX.XFRONT.XFE_O.BP.t4 VSS.t413 nfet_03v3 ad=2.08p pd=8.52u as=2.08p ps=8.52u w=8u l=0.28u
X538 XRX.XFRONT.XFE_O.XP.t34 XRX.XFRONT.XFE_O.SB.t9 XRX.XFRONT.XFE_O.NREGEN.t32 VSS.t549 nfet_03v3 ad=2.08p pd=8.52u as=2.08p ps=8.52u w=8u l=0.28u
X539 VSS.t323 RX_BIAS.t7 a_n5052_n1000.t4 VSS.t316 nfet_03v3 ad=2.6p pd=10.52u as=2.6p ps=10.52u w=10u l=0.28u
X540 VSS.t292 XRX.XFRONT.XFE_E.SXP.t17 XRX.XFRONT.XFE_E.BP.t5 VSS.t291 nfet_03v3 ad=2.08p pd=8.52u as=2.08p ps=8.52u w=8u l=0.28u
X541 XRX.XCAP.ODD_DB_BUF.t3 FE_O_P.t22 VDD.t41 VDD.t40 pfet_03v3 ad=2.08p pd=8.52u as=2.08p ps=8.52u w=8u l=0.28u
X542 VDD.t244 E_REGEN_CLK.t35 XRX.XFRONT.XFE_E.XN.t17 VDD.t243 pfet_03v3 ad=2.08p pd=8.52u as=3.52p ps=16.88u w=8u l=0.28u
X543 XRX.XFRONT.XFE_O.XP.t31 XRX.XFRONT.XFE_O.XN.t56 XRX.XFRONT.XFE_O.VREGP.t9 VDD.t295 pfet_03v3 ad=2.08p pd=8.52u as=2.08p ps=8.52u w=8u l=0.28u
X544 XRX.XCAP.O_QI.t11 XRX.XCAP.O_QBI.t16 VDD.t294 VDD.t79 pfet_03v3 ad=3.52p pd=16.88u as=2.08p ps=8.52u w=8u l=0.28u
X545 a_n7300_n19900.t1 TERM_EN2_N.t1 a_n6400_n19852.t1 VDD.t511 pfet_03v3 ad=4.4p pd=20.88u as=2.6p ps=10.52u w=10u l=0.28u
X546 XRX.XFRONT.XFE_O.VREGN.t12 XRX.XFRONT.XFE_O.XP.t53 XRX.XFRONT.XFE_O.XN.t9 VDD.t447 pfet_03v3 ad=2.08p pd=8.52u as=2.08p ps=8.52u w=8u l=0.28u
X547 FE_E_P.t8 XRX.XFRONT.XFE_E.BN.t22 VDD.t188 VDD.t187 pfet_03v3 ad=2.08p pd=8.52u as=2.08p ps=8.52u w=8u l=0.28u
X548 a_n6400_n18052.t2 RXN.t3 VSS.t310 ppolyf_u r_width=1u r_length=1u
X549 XRX.XFRONT.XFE_O.NTAIL.t7 O_SENSE_BOOST.t0 VSS.t243 VSS.t242 nfet_03v3 ad=3.52p pd=16.88u as=2.08p ps=8.52u w=8u l=0.28u
X550 XRX.XFRONT.XFE_E.XN.t2 XRX.XFRONT.XFE_E.SA.t13 XRX.XFRONT.XFE_E.NREGEN.t3 VSS.t89 nfet_03v3 ad=2.08p pd=8.52u as=2.08p ps=8.52u w=8u l=0.28u
X551 XRX.XCAP.O_RST_TAIL.t5 O_CAPTURE_CLK.t2 VSS.t63 VSS.t62 nfet_03v3 ad=2.08p pd=8.52u as=2.08p ps=8.52u w=8u l=0.28u
X552 VSS.t366 XRX.XFRONT.XFE_O.SXN.t17 XRX.XFRONT.XFE_O.BN.t5 VSS.t365 nfet_03v3 ad=2.08p pd=8.52u as=2.08p ps=8.52u w=8u l=0.28u
X553 a_75604_31500.t4 PHASE_A_N.t0 a_72548_31500.t7 VSS.t474 nfet_03v3 ad=2.2p pd=10.88u as=1.3p ps=5.52u w=5u l=0.28u
X554 ODD_QB.t1 XRX.XCAP.O_QBUF.t7 VDD.t302 VDD.t301 pfet_03v3 ad=3.52p pd=16.88u as=2.08p ps=8.52u w=8u l=0.28u
X555 XRX.XFRONT.XFE_E.VREGP.t1 E_REGEN_CLKB.t6 VDD.t214 VDD.t213 pfet_03v3 ad=2.08p pd=8.52u as=2.08p ps=8.52u w=8u l=0.28u
X556 XRX.XFRONT.XFE_E.XN.t14 XRX.XFRONT.XFE_E.XP.t35 XRX.XFRONT.XFE_E.NREGEN.t27 VSS.t382 nfet_03v3 ad=3.52p pd=16.88u as=2.08p ps=8.52u w=8u l=0.28u
X557 XRX.XCAP.E_SET_TAIL.t5 E_CAPTURE_CLK.t14 VSS.t258 VSS.t257 nfet_03v3 ad=2.08p pd=8.52u as=2.08p ps=8.52u w=8u l=0.28u
X558 VDD.t427 XRX.XFRONT.XFE_E.BP.t21 FE_E_N.t4 VDD.t426 pfet_03v3 ad=2.08p pd=8.52u as=2.08p ps=8.52u w=8u l=0.28u
X559 XRX.XFRONT.XFE_O.SA.t2 O_SENSE_CLK.t6 VDD.t118 VDD.t117 pfet_03v3 ad=3.52p pd=16.88u as=2.08p ps=8.52u w=8u l=0.28u
X560 XRX.XCAP.O_QI.t3 XRX.XCAP.ODD_DB_BUF.t14 XRX.XCAP.O_RST_TAIL.t10 VSS.t46 nfet_03v3 ad=2.08p pd=8.52u as=2.08p ps=8.52u w=8u l=0.28u
X561 XRX.XFRONT.XFE_O.NREGEN.t26 O_REGEN_CLK.t4 VSS.t534 VSS.t244 nfet_03v3 ad=2.08p pd=8.52u as=2.08p ps=8.52u w=8u l=0.28u
X562 VSS.t525 XRX.XCAP.O_QBUF.t6 ODD_QB.t6 VSS.t524 nfet_03v3 ad=2.08p pd=8.52u as=3.52p ps=16.88u w=8u l=0.28u
X563 EVEN_QB.t4 XRX.XCAP.E_QBUF.t5 VSS.t466 VSS.t465 nfet_03v3 ad=2.08p pd=8.52u as=2.08p ps=8.52u w=8u l=0.28u
X564 XRX.XFRONT.XFE_O.XP.t8 O_REGEN_CLK.t34 VDD.t518 VDD.t517 pfet_03v3 ad=2.08p pd=8.52u as=2.08p ps=8.52u w=8u l=0.28u
X565 VDD.t363 E_CAPTURE_CLKB.t1 XRX.XCAP.E_PSET_TAIL.t10 VDD.t351 pfet_03v3 ad=2.08p pd=8.52u as=2.08p ps=8.52u w=8u l=0.28u
X566 a_n6400_n14452.t1 TERM_EN5_N.t0 a_n7300_n14500.t1 VDD.t128 pfet_03v3 ad=2.6p pd=10.52u as=4.4p ps=20.88u w=10u l=0.28u
X567 RX_RAWP.t0 a_n6572_3500.t6 a_2148_n500.t0 VSS.t151 nfet_03v3 ad=2.2p pd=10.88u as=1.3p ps=5.52u w=5u l=0.28u
X568 EVEN_QB.t6 XRX.XCAP.E_QBUF.t7 VDD.t514 VDD.t513 pfet_03v3 ad=3.52p pd=16.88u as=2.08p ps=8.52u w=8u l=0.28u
X569 XRX.XCAP.E_QI.t9 XRX.XCAP.EVEN_DB_BUF.t14 XRX.XCAP.E_RST_TAIL.t3 VSS.t24 nfet_03v3 ad=2.08p pd=8.52u as=2.08p ps=8.52u w=8u l=0.28u
X570 XRX.XFRONT.XFE_E.SXN.t0 XRX.XFRONT.XFE_E.XN.t42 VDD.t199 VDD.t198 pfet_03v3 ad=3.52p pd=16.88u as=2.08p ps=8.52u w=8u l=0.28u
X571 XRX.XCAP.E_SET_TAIL.t1 XRX.XCAP.EVEN_D_BUF.t13 XRX.XCAP.E_QBI.t3 VSS.t37 nfet_03v3 ad=2.08p pd=8.52u as=2.08p ps=8.52u w=8u l=0.28u
X572 VDD.t170 a_600_22678.t0 VSS.t222 ppolyf_u r_width=2u r_length=4.2u
X573 VSS.t226 XRX.XCAP.E_QBI.t15 XRX.XCAP.E_QBUF.t3 VSS.t225 nfet_03v3 ad=1.04p pd=4.52u as=1.76p ps=8.88u w=4u l=0.28u
X574 XRX.XFRONT.XFE_E.XN.t29 E_REGEN_CLK.t23 XRX.XFRONT.XFE_E.XP.t22 VDD.t26 pfet_03v3 ad=2.08p pd=8.52u as=2.08p ps=8.52u w=8u l=0.28u
X575 XRX.XFRONT.XFE_O.XN.t16 XRX.XFRONT.XFE_O.XP.t50 XRX.XFRONT.XFE_O.VREGN.t15 VDD.t491 pfet_03v3 ad=3.52p pd=16.88u as=2.08p ps=8.52u w=8u l=0.28u
X576 XRX.XFRONT.XFE_O.SA.t4 O_SENSE_CLK.t4 XRX.XFRONT.XFE_O.SB.t3 VDD.t120 pfet_03v3 ad=3.52p pd=16.88u as=2.08p ps=8.52u w=8u l=0.28u
X577 XRX.XFRONT.XFE_O.BN.t2 XRX.XFRONT.XFE_O.SXN.t14 VSS.t358 VSS.t357 nfet_03v3 ad=2.08p pd=8.52u as=2.08p ps=8.52u w=8u l=0.28u
X578 a_10548_44200.t4 RX_RESTP.t4 SAMP_O_N.t1 VSS.t178 nfet_03v3 ad=1.56p pd=6.52u as=2.64p ps=12.88u w=6u l=0.28u
X579 RXP.t5 a_n7300_n14500.t2 VSS.t32 ppolyf_u r_width=1u r_length=1u
X580 VDD.t560 XRX.XFRONT.XFE_E.XP.t43 XRX.XFRONT.XFE_E.SXP.t11 VDD.t559 pfet_03v3 ad=2.08p pd=8.52u as=2.08p ps=8.52u w=8u l=0.28u
X581 a_74148_31500.t3 PI_CTRL_B.t0 VSS.t8 VSS.t7 nfet_03v3 ad=2.2p pd=10.88u as=1.3p ps=5.52u w=5u l=0.28u
X582 VSS.t348 XRX.XFRONT.XFE_O.BN.t13 FE_O_N.t3 VSS.t347 nfet_03v3 ad=2.08p pd=8.52u as=2.08p ps=8.52u w=8u l=0.28u
X583 VSS.t537 O_REGEN_CLK.t1 XRX.XFRONT.XFE_O.NREGEN.t29 VSS.t242 nfet_03v3 ad=2.08p pd=8.52u as=2.08p ps=8.52u w=8u l=0.28u
X584 XRX.XFRONT.XFE_O.XP.t29 XRX.XFRONT.XFE_O.XN.t36 XRX.XFRONT.XFE_O.NREGEN.t12 VSS.t304 nfet_03v3 ad=2.08p pd=8.52u as=2.08p ps=8.52u w=8u l=0.28u
X585 FE_E_P.t2 XRX.XFRONT.XFE_E.BN.t16 VDD.t174 VDD.t173 pfet_03v3 ad=3.52p pd=16.88u as=2.08p ps=8.52u w=8u l=0.28u
X586 a_11748_41600.t7 SAMP_BIAS.t0 VSS.t513 VSS.t512 nfet_03v3 ad=4.4p pd=20.88u as=2.6p ps=10.52u w=10u l=0.28u
X587 XRX.XFRONT.XFE_E.XN.t16 XRX.XFRONT.XFE_E.SA.t7 XRX.XFRONT.XFE_E.NREGEN.t12 VSS.t309 nfet_03v3 ad=3.52p pd=16.88u as=2.08p ps=8.52u w=8u l=0.28u
X588 VDD.t476 FE_E_N.t23 XRX.XCAP.EVEN_D_BUF.t2 VDD.t475 pfet_03v3 ad=2.08p pd=8.52u as=2.08p ps=8.52u w=8u l=0.28u
X589 XRX.XCAP.EVEN_DB_BUF.t1 FE_E_P.t24 VDD.t567 VDD.t566 pfet_03v3 ad=2.08p pd=8.52u as=2.08p ps=8.52u w=8u l=0.28u
X590 VSS.t114 PI_CTRL_A.t3 a_72548_31500.t2 VSS.t1 nfet_03v3 ad=1.3p pd=5.52u as=2.2p ps=10.88u w=5u l=0.28u
X591 VDD.t306 XRX.XCAP.E_QI.t17 XRX.XCAP.E_QBI.t8 VDD.t305 pfet_03v3 ad=2.08p pd=8.52u as=3.52p ps=16.88u w=8u l=0.28u
X592 XRX.XCAP.ODD_DB_BUF.t5 FE_O_P.t20 VDD.t45 VDD.t44 pfet_03v3 ad=2.08p pd=8.52u as=2.08p ps=8.52u w=8u l=0.28u
X593 XRX.XFRONT.XFE_E.VREGP.t7 E_REGEN_CLKB.t0 VDD.t236 VDD.t235 pfet_03v3 ad=3.52p pd=16.88u as=2.08p ps=8.52u w=8u l=0.28u
X594 VDD.t416 XRX.XFRONT.XFE_E.XN.t45 XRX.XFRONT.XFE_E.SXN.t7 VDD.t415 pfet_03v3 ad=2.08p pd=8.52u as=2.08p ps=8.52u w=8u l=0.28u
X595 VDD.t376 XRX.XFRONT.XFE_O.BP.t19 FE_O_P.t1 VDD.t375 pfet_03v3 ad=2.08p pd=8.52u as=2.08p ps=8.52u w=8u l=0.28u
X596 VDD.t197 RX_RESTN.t0 VSS.t222 ppolyf_u r_width=2u r_length=4.2u
X597 SAMP_E_N.t4 SAMP_E_P.t5 a_2548_44200.t1 VSS.t122 nfet_03v3 ad=2.64p pd=12.88u as=1.56p ps=6.52u w=6u l=0.28u
X598 VSS.t20 XRX.XCAP.O_QI.t13 XRX.XCAP.O_QBI.t2 VSS.t19 nfet_03v3 ad=2.08p pd=8.52u as=3.52p ps=16.88u w=8u l=0.28u
X599 a_n6572_3500.t5 VTHP.t0 a_n5052_2600.t7 VSS.t497 nfet_03v3 ad=0.88p pd=4.88u as=0.52p ps=2.52u w=2u l=0.28u
X600 XRX.XFRONT.XFE_E.XP.t19 E_REGEN_CLK.t26 XRX.XFRONT.XFE_E.XN.t26 VDD.t262 pfet_03v3 ad=2.08p pd=8.52u as=2.08p ps=8.52u w=8u l=0.28u
X601 a_65148_38800.t6 a_65000_32348.t4 PI_CLK_P.t1 VSS.t393 nfet_03v3 ad=2.6p pd=10.52u as=4.4p ps=20.88u w=10u l=0.28u
X602 VDD.t538 O_REGEN_CLK.t19 XRX.XFRONT.XFE_O.XN.t17 VDD.t537 pfet_03v3 ad=2.08p pd=8.52u as=3.52p ps=16.88u w=8u l=0.28u
X603 VSS.t39 O_CAPTURE_CLK.t15 XRX.XCAP.O_SET_TAIL.t0 VSS.t38 nfet_03v3 ad=2.08p pd=8.52u as=3.52p ps=16.88u w=8u l=0.28u
X604 VDD.t147 XRX.XFRONT.XFE_E.XP.t49 XRX.XFRONT.XFE_E.SXP.t5 VDD.t146 pfet_03v3 ad=2.08p pd=8.52u as=3.52p ps=16.88u w=8u l=0.28u
X605 a_2148_n500.t2 RX_BIAS.t3 VSS.t312 VSS.t311 nfet_03v3 ad=2.6p pd=10.52u as=2.6p ps=10.52u w=10u l=0.28u
X606 XRX.XFRONT.XFE_O.NREGEN.t2 XRX.XFRONT.XFE_O.SB.t12 XRX.XFRONT.XFE_O.XP.t1 VSS.t35 nfet_03v3 ad=2.08p pd=8.52u as=2.08p ps=8.52u w=8u l=0.28u
X607 XRX.XFRONT.XFE_O.VREGN.t7 O_REGEN_CLKB.t0 VDD.t342 VDD.t341 pfet_03v3 ad=3.52p pd=16.88u as=2.08p ps=8.52u w=8u l=0.28u
X608 XRX.XCAP.O_PSET_TAIL.t5 O_CAPTURE_CLKB.t6 VDD.t98 VDD.t88 pfet_03v3 ad=2.08p pd=8.52u as=2.08p ps=8.52u w=8u l=0.28u
X609 VDD.t398 XRX.XFRONT.XFE_O.XN.t49 XRX.XFRONT.XFE_O.SXN.t8 VDD.t397 pfet_03v3 ad=2.08p pd=8.52u as=3.52p ps=16.88u w=8u l=0.28u
X610 a_n10800_n17972.t0 TERM_EN3_N.t3 VDD.t5 VDD.t4 pfet_03v3 ad=0.88p pd=4.88u as=0.88p ps=4.88u w=2u l=0.28u
X611 SAMP_O_P.t3 SAMP_O_N.t5 a_12148_44200.t5 VSS.t485 nfet_03v3 ad=2.64p pd=12.88u as=1.56p ps=6.52u w=6u l=0.28u
X612 XRX.XCAP.E_RST_TAIL.t9 E_CAPTURE_CLK.t2 VSS.t275 VSS.t36 nfet_03v3 ad=2.08p pd=8.52u as=2.08p ps=8.52u w=8u l=0.28u
X613 VDD.t202 a_n1900_5958.t0 VSS.t280 ppolyf_u r_width=1u r_length=1.4u
X614 a_n7157_n21700.t3 TERM_EN1_N.t1 a_n6400_n21652.t3 VDD.t507 pfet_03v3 ad=4.4p pd=20.88u as=2.6p ps=10.52u w=10u l=0.28u
X615 XRX.XFRONT.XFE_E.NTAIL.t7 E_SENSE_BOOST.t4 VSS.t477 VSS.t335 nfet_03v3 ad=2.08p pd=8.52u as=2.08p ps=8.52u w=8u l=0.28u
X616 VDD.t493 XRX.XFRONT.XFE_O.XP.t45 XRX.XFRONT.XFE_O.SXP.t8 VDD.t492 pfet_03v3 ad=2.08p pd=8.52u as=2.08p ps=8.52u w=8u l=0.28u
X617 XRX.XFRONT.XFE_O.XN.t31 O_REGEN_CLK.t21 XRX.XFRONT.XFE_O.XP.t21 VDD.t535 pfet_03v3 ad=2.08p pd=8.52u as=2.08p ps=8.52u w=8u l=0.28u
X618 XRX.XFRONT.XFE_O.XN.t8 XRX.XFRONT.XFE_O.XP.t56 XRX.XFRONT.XFE_O.VREGN.t9 VDD.t446 pfet_03v3 ad=2.08p pd=8.52u as=2.08p ps=8.52u w=8u l=0.28u
X619 VDD.t182 XRX.XFRONT.XFE_E.BN.t19 FE_E_P.t5 VDD.t181 pfet_03v3 ad=2.08p pd=8.52u as=2.08p ps=8.52u w=8u l=0.28u
X620 a_65148_29400.t7 PI_RAW_P.t4 a_65000_32348.t1 VSS.t393 nfet_03v3 ad=2.6p pd=10.52u as=4.4p ps=20.88u w=10u l=0.28u
X621 VSS.t60 O_CAPTURE_CLK.t5 XRX.XCAP.O_RST_TAIL.t2 VSS.t59 nfet_03v3 ad=2.08p pd=8.52u as=2.08p ps=8.52u w=8u l=0.28u
X622 XRX.XCAP.O_QBUF.t1 XRX.XCAP.O_QBI.t14 VSS.t189 VSS.t188 nfet_03v3 ad=1.76p pd=8.88u as=1.04p ps=4.52u w=4u l=0.28u
X623 FE_E_N.t7 XRX.XFRONT.XFE_E.BP.t18 VDD.t433 VDD.t432 pfet_03v3 ad=2.08p pd=8.52u as=2.08p ps=8.52u w=8u l=0.28u
X624 VDD.t230 E_REGEN_CLKB.t3 XRX.XFRONT.XFE_E.VREGP.t4 VDD.t229 pfet_03v3 ad=2.08p pd=8.52u as=2.08p ps=8.52u w=8u l=0.28u
X625 VDD.t346 E_CAPTURE_CLKB.t5 XRX.XCAP.E_PSET_TAIL.t6 VDD.t345 pfet_03v3 ad=2.08p pd=8.52u as=2.08p ps=8.52u w=8u l=0.28u
X626 FE_O_P.t6 XRX.XFRONT.XFE_O.BP.t16 VDD.t384 VDD.t383 pfet_03v3 ad=3.52p pd=16.88u as=2.08p ps=8.52u w=8u l=0.28u
X627 XRX.XCAP.O_PRST_TAIL.t10 XRX.XCAP.ODD_D_BUF.t17 XRX.XCAP.O_QBI.t8 VDD.t79 pfet_03v3 ad=2.08p pd=8.52u as=2.08p ps=8.52u w=8u l=0.28u
X628 a_n7300_n12700.t4 a_n10800_n12572.t3 a_n6400_n12652.t4 VSS.t427 nfet_03v3 ad=4.4p pd=20.88u as=2.6p ps=10.52u w=10u l=0.28u
X629 XRX.XCAP.O_PRST_TAIL.t5 O_CAPTURE_CLKB.t10 VDD.t93 VDD.t92 pfet_03v3 ad=2.08p pd=8.52u as=2.08p ps=8.52u w=8u l=0.28u
X630 VDD.t114 XRX.XFRONT.XFE_O.BN.t23 FE_O_N.t2 VDD.t113 pfet_03v3 ad=2.08p pd=8.52u as=3.52p ps=16.88u w=8u l=0.28u
X631 XRX.XFRONT.XFE_E.NREGEN.t14 E_REGEN_CLK.t10 VDD.t238 VDD.t237 pfet_03v3 ad=3.52p pd=16.88u as=2.08p ps=8.52u w=8u l=0.28u
X632 FE_E_P.t10 XRX.XFRONT.XFE_E.BN.t10 VSS.t436 VSS.t435 nfet_03v3 ad=3.52p pd=16.88u as=2.08p ps=8.52u w=8u l=0.28u
X633 VDD.t218 E_REGEN_CLKB.t9 XRX.XFRONT.XFE_E.VREGN.t14 VDD.t217 pfet_03v3 ad=2.08p pd=8.52u as=2.08p ps=8.52u w=8u l=0.28u
X634 VDD.t318 O_REGEN_CLKB.t15 XRX.XFRONT.XFE_O.VREGP.t0 VDD.t317 pfet_03v3 ad=2.08p pd=8.52u as=3.52p ps=16.88u w=8u l=0.28u
X635 XRX.XCAP.E_PRST_TAIL.t3 XRX.XCAP.EVEN_D_BUF.t19 XRX.XCAP.E_QBI.t7 VDD.t72 pfet_03v3 ad=2.08p pd=8.52u as=3.52p ps=16.88u w=8u l=0.28u
X636 EVEN_Q.t1 XRX.XCAP.E_QBBUF.t9 VDD.t20 VDD.t19 pfet_03v3 ad=2.08p pd=8.52u as=2.08p ps=8.52u w=8u l=0.28u
X637 XRX.XFRONT.XFE_E.XN.t7 XRX.XFRONT.XFE_E.XP.t56 XRX.XFRONT.XFE_E.VREGN.t1 VDD.t166 pfet_03v3 ad=2.08p pd=8.52u as=2.08p ps=8.52u w=8u l=0.28u
X638 XRX.XFRONT.XFE_E.SA.t2 E_SENSE_CLK.t4 XRX.XFRONT.XFE_E.SB.t3 VDD.t26 pfet_03v3 ad=3.52p pd=16.88u as=2.08p ps=8.52u w=8u l=0.28u
X639 VDD.t68 a_n6716_3500.t0 VSS.t165 ppolyf_u r_width=1u r_length=1.4u
X640 a_n5052_2600.t6 VTHP.t1 a_n6572_3500.t4 VSS.t497 nfet_03v3 ad=0.52p pd=2.52u as=0.88p ps=4.88u w=2u l=0.28u
X641 XRX.XFRONT.XFE_E.BN.t5 XRX.XFRONT.XFE_E.SXN.t16 VSS.t104 VSS.t103 nfet_03v3 ad=2.08p pd=8.52u as=2.08p ps=8.52u w=8u l=0.28u
X642 a_n6400_n18052.t0 TERM_EN3_N.t0 a_n7300_n18100.t1 VDD.t7 pfet_03v3 ad=2.6p pd=10.52u as=4.4p ps=20.88u w=10u l=0.28u
X643 a_11748_41600.t1 PI_CLK_P.t4 a_12148_44200.t0 VSS.t98 nfet_03v3 ad=2.08p pd=8.52u as=3.52p ps=16.88u w=8u l=0.28u
X644 VSS.t426 XRX.XFRONT.XFE_O.SXP.t15 XRX.XFRONT.XFE_O.BP.t6 VSS.t425 nfet_03v3 ad=2.08p pd=8.52u as=2.08p ps=8.52u w=8u l=0.28u
X645 XRX.XFRONT.XFE_O.SXP.t4 XRX.XFRONT.XFE_O.XP.t42 VDD.t141 VDD.t140 pfet_03v3 ad=3.52p pd=16.88u as=2.08p ps=8.52u w=8u l=0.28u
X646 XRX.XFRONT.XFE_E.XP.t17 E_REGEN_CLK.t20 XRX.XFRONT.XFE_E.XN.t32 VDD.t266 pfet_03v3 ad=3.52p pd=16.88u as=2.08p ps=8.52u w=8u l=0.28u
X647 VSS.t230 XRX.XFRONT.XFE_E.SXP.t19 XRX.XFRONT.XFE_E.BP.t0 VSS.t229 nfet_03v3 ad=2.08p pd=8.52u as=3.52p ps=16.88u w=8u l=0.28u
X648 a_5300_5958.t0 RX_BW_EN_N.t0 RX_RAWN.t1 VDD.t368 pfet_03v3 ad=2.2p pd=10.88u as=2.2p ps=10.88u w=5u l=0.28u
X649 XRX.XFRONT.XFE_O.VREGN.t1 O_REGEN_CLKB.t6 VDD.t312 VDD.t311 pfet_03v3 ad=2.08p pd=8.52u as=2.08p ps=8.52u w=8u l=0.28u
X650 XRX.XFRONT.XFE_O.XP.t33 XRX.XFRONT.XFE_O.XN.t54 XRX.XFRONT.XFE_O.VREGP.t11 VDD.t290 pfet_03v3 ad=2.08p pd=8.52u as=2.08p ps=8.52u w=8u l=0.28u
X651 VSS.t336 E_REGEN_CLK.t5 XRX.XFRONT.XFE_E.NREGEN.t19 VSS.t335 nfet_03v3 ad=2.08p pd=8.52u as=2.08p ps=8.52u w=8u l=0.28u
X652 VDD.t482 FE_E_N.t19 XRX.XCAP.EVEN_D_BUF.t6 VDD.t481 pfet_03v3 ad=2.08p pd=8.52u as=2.08p ps=8.52u w=8u l=0.28u
X653 VSS.t2 PI_CTRL_B.t3 a_74148_31500.t0 VSS.t1 nfet_03v3 ad=1.3p pd=5.52u as=2.2p ps=10.88u w=5u l=0.28u
X654 VSS.t442 XRX.XFRONT.XFE_E.BN.t13 FE_E_P.t13 VSS.t441 nfet_03v3 ad=2.08p pd=8.52u as=2.08p ps=8.52u w=8u l=0.28u
X655 VDD.t70 a_n3600_5641.t0 VSS.t167 ppolyf_u r_width=2u r_length=4.57u
X656 RXP.t6 a_n7300_n18100.t2 VSS.t32 ppolyf_u r_width=1u r_length=1u
X657 VDD.t31 PI_RAW_P.t0 VSS.t91 ppolyf_u r_width=2u r_length=5.25u
X658 VSS.t459 XRX.XCAP.E_QI.t13 XRX.XCAP.E_QBI.t10 VSS.t85 nfet_03v3 ad=2.08p pd=8.52u as=3.52p ps=16.88u w=8u l=0.28u
X659 VSS.t507 SAMP_BIAS.t3 a_11748_41600.t4 VSS.t506 nfet_03v3 ad=2.6p pd=10.52u as=4.4p ps=20.88u w=10u l=0.28u
X660 a_2148_41600.t5 SAMP_BIAS.t6 VSS.t499 VSS.t498 nfet_03v3 ad=2.6p pd=10.52u as=2.6p ps=10.52u w=10u l=0.28u
X661 XRX.XCAP.O_PSET_TAIL.t1 XRX.XCAP.ODD_DB_BUF.t19 XRX.XCAP.O_QI.t5 VDD.t73 pfet_03v3 ad=2.08p pd=8.52u as=3.52p ps=16.88u w=8u l=0.28u
X662 VDD.t460 XRX.XCAP.O_QBBUF.t8 ODD_Q.t2 VDD.t459 pfet_03v3 ad=2.08p pd=8.52u as=2.08p ps=8.52u w=8u l=0.28u
X663 VDD.t206 E_REGEN_CLKB.t15 XRX.XFRONT.XFE_E.VREGN.t8 VDD.t205 pfet_03v3 ad=2.08p pd=8.52u as=3.52p ps=16.88u w=8u l=0.28u
X664 FE_O_P.t4 XRX.XFRONT.XFE_O.BP.t22 VDD.t382 VDD.t381 pfet_03v3 ad=2.08p pd=8.52u as=2.08p ps=8.52u w=8u l=0.28u
X665 VSS.t548 XRX.XFRONT.XFE_E.XN.t39 XRX.XFRONT.XFE_E.SXN.t11 VSS.t547 nfet_03v3 ad=2.08p pd=8.52u as=2.08p ps=8.52u w=8u l=0.28u
X666 XRX.XFRONT.XFE_O.XN.t33 XRX.XFRONT.XFE_O.SA.t9 XRX.XFRONT.XFE_O.NREGEN.t31 VSS.t540 nfet_03v3 ad=2.08p pd=8.52u as=2.08p ps=8.52u w=8u l=0.28u
X667 XRX.XFRONT.XFE_O.BP.t9 XRX.XFRONT.XFE_O.SXP.t12 VSS.t420 VSS.t419 nfet_03v3 ad=3.52p pd=16.88u as=2.08p ps=8.52u w=8u l=0.28u
X668 VSS.t517 XRX.XCAP.O_QBUF.t4 ODD_QB.t3 VSS.t516 nfet_03v3 ad=3.52p pd=16.88u as=2.08p ps=8.52u w=8u l=0.28u
X669 a_72548_31500.t1 PHASE_A_P.t1 a_72404_31500.t0 VSS.t30 nfet_03v3 ad=1.3p pd=5.52u as=2.2p ps=10.88u w=5u l=0.28u
X670 XRX.XFRONT.XFE_O.XP.t10 O_REGEN_CLK.t32 VDD.t524 VDD.t115 pfet_03v3 ad=2.08p pd=8.52u as=2.08p ps=8.52u w=8u l=0.28u
X671 XRX.XCAP.E_PSET_TAIL.t1 XRX.XCAP.EVEN_DB_BUF.t17 XRX.XCAP.E_QI.t6 VDD.t1 pfet_03v3 ad=2.08p pd=8.52u as=2.08p ps=8.52u w=8u l=0.28u
X672 VDD.t338 O_REGEN_CLKB.t3 XRX.XFRONT.XFE_O.VREGN.t4 VDD.t337 pfet_03v3 ad=2.08p pd=8.52u as=2.08p ps=8.52u w=8u l=0.28u
X673 XRX.XFRONT.XFE_O.VREGP.t14 XRX.XFRONT.XFE_O.XN.t51 XRX.XFRONT.XFE_O.XP.t24 VDD.t418 pfet_03v3 ad=2.08p pd=8.52u as=2.08p ps=8.52u w=8u l=0.28u
X674 XRX.XCAP.E_PRST_TAIL.t7 E_CAPTURE_CLKB.t12 VDD.t355 VDD.t305 pfet_03v3 ad=2.08p pd=8.52u as=2.08p ps=8.52u w=8u l=0.28u
X675 XRX.XCAP.ODD_D_BUF.t1 FE_O_N.t24 VDD.t155 VDD.t154 pfet_03v3 ad=2.08p pd=8.52u as=2.08p ps=8.52u w=8u l=0.28u
X676 VSS.t272 E_CAPTURE_CLK.t5 XRX.XCAP.E_RST_TAIL.t6 VSS.t86 nfet_03v3 ad=2.08p pd=8.52u as=2.08p ps=8.52u w=8u l=0.28u
X677 a_n3600_5641.t2 RXN.t8 a_n5052_n1000.t1 VSS.t151 nfet_03v3 ad=4.4p pd=20.88u as=2.6p ps=10.52u w=10u l=0.28u
X678 RX_RESTP.t2 a_n1000_22678.t3 a_n852_28800.t7 VSS.t88 nfet_03v3 ad=4.4p pd=20.88u as=2.6p ps=10.52u w=10u l=0.28u
X679 XRX.XFRONT.XFE_E.XN.t15 XRX.XFRONT.XFE_E.XP.t50 XRX.XFRONT.XFE_E.VREGN.t7 VDD.t133 pfet_03v3 ad=3.52p pd=16.88u as=2.08p ps=8.52u w=8u l=0.28u
X680 VSS.t554 XRX.XFRONT.XFE_O.XP.t39 XRX.XFRONT.XFE_O.SXP.t11 VSS.t553 nfet_03v3 ad=2.08p pd=8.52u as=2.08p ps=8.52u w=8u l=0.28u
X681 VSS.t479 E_SENSE_BOOST.t1 XRX.XFRONT.XFE_E.NTAIL.t10 VSS.t339 nfet_03v3 ad=2.08p pd=8.52u as=2.08p ps=8.52u w=8u l=0.28u
X682 XRX.XFRONT.XFE_O.SXP.t6 XRX.XFRONT.XFE_O.XP.t48 VDD.t454 VDD.t453 pfet_03v3 ad=2.08p pd=8.52u as=2.08p ps=8.52u w=8u l=0.28u
X683 XRX.XFRONT.XFE_E.NREGEN.t1 XRX.XFRONT.XFE_E.SB.t8 XRX.XFRONT.XFE_E.XP.t0 VSS.t16 nfet_03v3 ad=2.08p pd=8.52u as=2.08p ps=8.52u w=8u l=0.28u
X684 XRX.XFRONT.XFE_O.BN.t0 XRX.XFRONT.XFE_O.SXN.t12 VSS.t354 VSS.t353 nfet_03v3 ad=3.52p pd=16.88u as=2.08p ps=8.52u w=8u l=0.28u
X685 XRX.XFRONT.XFE_O.XP.t18 O_REGEN_CLK.t24 XRX.XFRONT.XFE_O.XN.t28 VDD.t119 pfet_03v3 ad=2.08p pd=8.52u as=2.08p ps=8.52u w=8u l=0.28u
X686 VSS.t519 XRX.XCAP.E_QBBUF.t6 EVEN_Q.t6 VSS.t518 nfet_03v3 ad=2.08p pd=8.52u as=3.52p ps=16.88u w=8u l=0.28u
X687 XRX.XCAP.O_QBI.t11 XRX.XCAP.ODD_D_BUF.t14 XRX.XCAP.O_SET_TAIL.t11 VSS.t19 nfet_03v3 ad=2.08p pd=8.52u as=2.08p ps=8.52u w=8u l=0.28u
X688 VDD.t528 O_REGEN_CLK.t29 XRX.XFRONT.XFE_O.XP.t13 VDD.t527 pfet_03v3 ad=2.08p pd=8.52u as=2.08p ps=8.52u w=8u l=0.28u
X689 a_n1000_22678.t1 RX_RAWP.t4 a_n852_19400.t0 VSS.t88 nfet_03v3 ad=4.4p pd=20.88u as=2.6p ps=10.52u w=10u l=0.28u
X690 XRX.XFRONT.XFE_E.XN.t4 XRX.XFRONT.XFE_E.SA.t9 XRX.XFRONT.XFE_E.NREGEN.t5 VSS.t93 nfet_03v3 ad=2.08p pd=8.52u as=2.08p ps=8.52u w=8u l=0.28u
X691 VSS.t494 FE_E_N.t15 XRX.XCAP.EVEN_D_BUF.t10 VSS.t460 nfet_03v3 ad=2.08p pd=8.52u as=2.08p ps=8.52u w=8u l=0.28u
X692 VDD.t169 SAMP_E_P.t4 VSS.t221 ppolyf_u r_width=2u r_length=5u
X693 XRX.XCAP.ODD_D_BUF.t9 FE_O_N.t16 VSS.t205 VSS.t204 nfet_03v3 ad=2.08p pd=8.52u as=2.08p ps=8.52u w=8u l=0.28u
X694 VDD.t468 RX_RAWP.t2 VSS.t472 ppolyf_u r_width=2u r_length=3.43u
X695 a_n7300_n16300.t3 a_n10800_n16172.t3 a_n6400_n16252.t2 VSS.t228 nfet_03v3 ad=4.4p pd=20.88u as=2.6p ps=10.52u w=10u l=0.28u
X696 a_n852_19400.t3 REST_BIAS.t2 VSS.t160 VSS.t154 nfet_03v3 ad=3.12p pd=12.52u as=3.12p ps=12.52u w=12u l=0.28u
X697 VSS.t113 PI_CTRL_A.t1 a_72548_31500.t4 VSS.t5 nfet_03v3 ad=1.3p pd=5.52u as=1.3p ps=5.52u w=5u l=0.28u
X698 a_n10800_n14372.t1 TERM_EN5_N.t2 VSS.t186 VSS.t14 nfet_03v3 ad=0.44p pd=2.88u as=0.44p ps=2.88u w=1u l=0.28u
X699 a_2148_41600.t1 PI_CLK_P.t6 a_948_44200.t2 VSS.t96 nfet_03v3 ad=2.08p pd=8.52u as=3.52p ps=16.88u w=8u l=0.28u
X700 VDD.t404 XRX.XFRONT.XFE_E.XN.t47 XRX.XFRONT.XFE_E.SXN.t5 VDD.t403 pfet_03v3 ad=2.08p pd=8.52u as=2.08p ps=8.52u w=8u l=0.28u
X701 a_80148_31500.t6 a_75604_31500.t6 PI_RAW_N.t1 VSS.t428 nfet_03v3 ad=1.3p pd=5.52u as=2.2p ps=10.88u w=5u l=0.28u
X702 XRX.XFRONT.XFE_E.VREGN.t4 XRX.XFRONT.XFE_E.XP.t53 XRX.XFRONT.XFE_E.XN.t10 VDD.t496 pfet_03v3 ad=2.08p pd=8.52u as=2.08p ps=8.52u w=8u l=0.28u
X703 XRX.XFRONT.XFE_E.XP.t4 XRX.XFRONT.XFE_E.SB.t11 XRX.XFRONT.XFE_E.NREGEN.t9 VSS.t210 nfet_03v3 ad=2.08p pd=8.52u as=2.08p ps=8.52u w=8u l=0.28u
X704 VSS.t298 XRX.XFRONT.XFE_E.SXN.t13 XRX.XFRONT.XFE_E.BN.t8 VSS.t297 nfet_03v3 ad=2.08p pd=8.52u as=2.08p ps=8.52u w=8u l=0.28u
X705 VDD.t443 XRX.XFRONT.XFE_E.SXN.t21 XRX.XFRONT.XFE_E.BN.t0 VDD.t442 pfet_03v3 ad=2.08p pd=8.52u as=3.52p ps=16.88u w=8u l=0.28u
X706 XRX.XFRONT.XFE_O.BP.t3 XRX.XFRONT.XFE_O.SXP.t18 VSS.t416 VSS.t415 nfet_03v3 ad=2.08p pd=8.52u as=2.08p ps=8.52u w=8u l=0.28u
X707 XRX.XFRONT.XFE_O.BP.t1 XRX.XFRONT.XFE_O.SXP.t20 VDD.t390 VDD.t389 pfet_03v3 ad=3.52p pd=16.88u as=2.08p ps=8.52u w=8u l=0.28u
X708 a_2148_n500.t4 RX_BIAS.t1 VSS.t327 VSS.t311 nfet_03v3 ad=2.6p pd=10.52u as=2.6p ps=10.52u w=10u l=0.28u
X709 a_n5052_n1000.t5 RX_BIAS.t6 VSS.t324 VSS.t311 nfet_03v3 ad=2.6p pd=10.52u as=2.6p ps=10.52u w=10u l=0.28u
X710 a_n10800_n23372.t0 TERM_EN0_N.t3 VDD.t370 VDD.t369 pfet_03v3 ad=0.88p pd=4.88u as=0.88p ps=4.88u w=2u l=0.28u
X711 XRX.XFRONT.XFE_E.NREGEN.t22 E_REGEN_CLK.t2 VSS.t340 VSS.t339 nfet_03v3 ad=2.08p pd=8.52u as=2.08p ps=8.52u w=8u l=0.28u
X712 XRX.XCAP.O_QI.t7 XRX.XCAP.ODD_DB_BUF.t16 XRX.XCAP.O_PSET_TAIL.t2 VDD.t78 pfet_03v3 ad=3.52p pd=16.88u as=2.08p ps=8.52u w=8u l=0.28u
X713 XRX.XFRONT.XFE_O.XN.t10 XRX.XFRONT.XFE_O.XP.t54 XRX.XFRONT.XFE_O.VREGN.t11 VDD.t448 pfet_03v3 ad=2.08p pd=8.52u as=2.08p ps=8.52u w=8u l=0.28u
X714 VDD.t186 XRX.XFRONT.XFE_E.BN.t21 FE_E_P.t7 VDD.t185 pfet_03v3 ad=2.08p pd=8.52u as=2.08p ps=8.52u w=8u l=0.28u
X715 XRX.XFRONT.XFE_O.BN.t6 XRX.XFRONT.XFE_O.SXN.t18 VSS.t368 VSS.t367 nfet_03v3 ad=2.08p pd=8.52u as=2.08p ps=8.52u w=8u l=0.28u
X716 XRX.XFRONT.XFE_E.NREGEN.t4 XRX.XFRONT.XFE_E.SA.t12 XRX.XFRONT.XFE_E.XN.t3 VSS.t90 nfet_03v3 ad=2.08p pd=8.52u as=2.08p ps=8.52u w=8u l=0.28u
X717 VSS.t61 O_CAPTURE_CLK.t3 XRX.XCAP.O_RST_TAIL.t4 VSS.t17 nfet_03v3 ad=2.08p pd=8.52u as=2.08p ps=8.52u w=8u l=0.28u
X718 a_72548_31500.t6 PHASE_A_N.t1 a_75604_31500.t3 VSS.t473 nfet_03v3 ad=1.3p pd=5.52u as=2.2p ps=10.88u w=5u l=0.28u
X719 a_n852_28800.t1 REST_BIAS.t6 VSS.t155 VSS.t154 nfet_03v3 ad=3.12p pd=12.52u as=3.12p ps=12.52u w=12u l=0.28u
X720 VSS.t82 E_SENSE_CLK.t1 XRX.XFRONT.XFE_E.NTAIL.t0 VSS.t81 nfet_03v3 ad=2.08p pd=8.52u as=3.52p ps=16.88u w=8u l=0.28u
X721 VSS.t254 E_CAPTURE_CLK.t13 XRX.XCAP.E_SET_TAIL.t6 VSS.t28 nfet_03v3 ad=2.08p pd=8.52u as=2.08p ps=8.52u w=8u l=0.28u
X722 XRX.XFRONT.XFE_O.XN.t22 O_REGEN_CLK.t14 VDD.t550 VDD.t549 pfet_03v3 ad=2.08p pd=8.52u as=2.08p ps=8.52u w=8u l=0.28u
X723 VDD.t110 XRX.XFRONT.XFE_O.BN.t21 FE_O_N.t0 VDD.t109 pfet_03v3 ad=2.08p pd=8.52u as=2.08p ps=8.52u w=8u l=0.28u
X724 VDD.t116 O_SENSE_CLK.t7 XRX.XFRONT.XFE_O.SA.t1 VDD.t115 pfet_03v3 ad=2.08p pd=8.52u as=3.52p ps=16.88u w=8u l=0.28u
X725 VDD.t352 E_CAPTURE_CLKB.t9 XRX.XCAP.E_PRST_TAIL.t10 VDD.t351 pfet_03v3 ad=2.08p pd=8.52u as=2.08p ps=8.52u w=8u l=0.28u
X726 VDD.t165 XRX.XCAP.O_QI.t19 XRX.XCAP.O_QBBUF.t0 VDD.t156 pfet_03v3 ad=2.08p pd=8.52u as=3.52p ps=16.88u w=8u l=0.28u
X727 a_n7300_n19900.t3 a_n10800_n19772.t3 a_n6400_n19852.t3 VSS.t541 nfet_03v3 ad=4.4p pd=20.88u as=2.6p ps=10.52u w=10u l=0.28u
X728 XRX.XFRONT.XFE_O.NREGEN.t17 XRX.XFRONT.XFE_O.SA.t12 XRX.XFRONT.XFE_O.XN.t14 VSS.t469 nfet_03v3 ad=2.08p pd=8.52u as=2.08p ps=8.52u w=8u l=0.28u
X729 XRX.XFRONT.XFE_O.XP.t4 XRX.XFRONT.XFE_O.SB.t7 XRX.XFRONT.XFE_O.NREGEN.t8 VSS.t200 nfet_03v3 ad=3.52p pd=16.88u as=2.08p ps=8.52u w=8u l=0.28u
X730 VSS.t317 RX_BIAS.t9 a_n5052_n1000.t2 VSS.t316 nfet_03v3 ad=2.6p pd=10.52u as=4.4p ps=20.88u w=10u l=0.28u
X731 XRX.XFRONT.XFE_E.XP.t10 E_REGEN_CLK.t16 VDD.t269 VDD.t27 pfet_03v3 ad=2.08p pd=8.52u as=2.08p ps=8.52u w=8u l=0.28u
X732 a_n6400_n23452.t2 RXN.t5 VSS.t395 ppolyf_u r_width=1u r_length=2.43u
X733 XRX.XFRONT.XFE_O.SXN.t9 XRX.XFRONT.XFE_O.XN.t44 VDD.t406 VDD.t405 pfet_03v3 ad=2.08p pd=8.52u as=2.08p ps=8.52u w=8u l=0.28u
X734 a_n6400_n23452.t3 TERM_EN0_N.t0 a_n7157_n23500.t4 VDD.t372 pfet_03v3 ad=2.6p pd=10.52u as=4.4p ps=20.88u w=10u l=0.28u
X735 XRX.XCAP.EVEN_DB_BUF.t5 FE_E_P.t20 VDD.t569 VDD.t568 pfet_03v3 ad=2.08p pd=8.52u as=2.08p ps=8.52u w=8u l=0.28u
X736 XRX.XCAP.E_RST_TAIL.t2 XRX.XCAP.EVEN_DB_BUF.t13 XRX.XCAP.E_QI.t10 VSS.t22 nfet_03v3 ad=2.08p pd=8.52u as=2.08p ps=8.52u w=8u l=0.28u
X737 XRX.XFRONT.XFE_O.NTAIL.t1 O_SENSE_CLK.t0 VSS.t185 VSS.t184 nfet_03v3 ad=3.52p pd=16.88u as=2.08p ps=8.52u w=8u l=0.28u
X738 XRX.XCAP.ODD_DB_BUF.t1 FE_O_P.t24 VDD.t35 VDD.t34 pfet_03v3 ad=2.08p pd=8.52u as=2.08p ps=8.52u w=8u l=0.28u
X739 XRX.XCAP.E_QBI.t4 XRX.XCAP.EVEN_D_BUF.t14 XRX.XCAP.E_SET_TAIL.t2 VSS.t85 nfet_03v3 ad=2.08p pd=8.52u as=2.08p ps=8.52u w=8u l=0.28u
X740 XRX.XFRONT.XFE_E.XP.t15 E_REGEN_CLK.t22 XRX.XFRONT.XFE_E.XN.t30 VDD.t264 pfet_03v3 ad=2.08p pd=8.52u as=2.08p ps=8.52u w=8u l=0.28u
X741 XRX.XFRONT.XFE_O.VREGN.t14 XRX.XFRONT.XFE_O.XP.t51 XRX.XFRONT.XFE_O.XN.t11 VDD.t449 pfet_03v3 ad=2.08p pd=8.52u as=2.08p ps=8.52u w=8u l=0.28u
X742 XRX.XFRONT.XFE_O.SA.t6 SAMP_O_P.t7 XRX.XFRONT.XFE_O.NTAIL.t9 VSS.t390 nfet_03v3 ad=3.52p pd=16.88u as=2.08p ps=8.52u w=8u l=0.28u
X743 XRX.XFRONT.XFE_O.SB.t4 O_SENSE_CLK.t5 XRX.XFRONT.XFE_O.SA.t3 VDD.t119 pfet_03v3 ad=2.08p pd=8.52u as=3.52p ps=16.88u w=8u l=0.28u
X744 VSS.t360 XRX.XFRONT.XFE_O.SXN.t15 XRX.XFRONT.XFE_O.BN.t3 VSS.t359 nfet_03v3 ad=2.08p pd=8.52u as=2.08p ps=8.52u w=8u l=0.28u
X745 XRX.XCAP.O_RST_TAIL.t7 O_CAPTURE_CLK.t0 VSS.t65 VSS.t64 nfet_03v3 ad=3.52p pd=16.88u as=2.08p ps=8.52u w=8u l=0.28u
X746 a_n6400_n14452.t3 a_n10800_n14372.t2 a_n7300_n14500.t3 VSS.t373 nfet_03v3 ad=2.6p pd=10.52u as=4.4p ps=20.88u w=10u l=0.28u
X747 XRX.XCAP.O_PSET_TAIL.t7 O_CAPTURE_CLKB.t4 VDD.t101 VDD.t58 pfet_03v3 ad=2.08p pd=8.52u as=2.08p ps=8.52u w=8u l=0.28u
X748 XRX.XFRONT.XFE_E.XN.t12 XRX.XFRONT.XFE_E.XP.t37 XRX.XFRONT.XFE_E.NREGEN.t29 VSS.t384 nfet_03v3 ad=2.08p pd=8.52u as=3.52p ps=16.88u w=8u l=0.28u
X749 VSS.t6 PI_CTRL_B.t1 a_74148_31500.t2 VSS.t5 nfet_03v3 ad=1.3p pd=5.52u as=1.3p ps=5.52u w=5u l=0.28u
X750 a_72404_31500.t3 PHASE_B_P.t0 a_74148_31500.t5 VSS.t95 nfet_03v3 ad=2.2p pd=10.88u as=1.3p ps=5.52u w=5u l=0.28u
X751 FE_O_N.t8 XRX.XFRONT.XFE_O.BN.t18 VDD.t284 VDD.t283 pfet_03v3 ad=2.08p pd=8.52u as=2.08p ps=8.52u w=8u l=0.28u
X752 XRX.XCAP.E_QI.t2 XRX.XCAP.E_QBI.t16 VDD.t80 VDD.t1 pfet_03v3 ad=3.52p pd=16.88u as=2.08p ps=8.52u w=8u l=0.28u
X753 XRX.XFRONT.XFE_E.SXP.t10 XRX.XFRONT.XFE_E.XP.t42 VDD.t558 VDD.t557 pfet_03v3 ad=3.52p pd=16.88u as=2.08p ps=8.52u w=8u l=0.28u
X754 VSS.t234 XRX.XFRONT.XFE_E.BN.t15 FE_E_P.t1 VSS.t233 nfet_03v3 ad=2.08p pd=8.52u as=3.52p ps=16.88u w=8u l=0.28u
X755 VSS.t511 SAMP_BIAS.t1 a_11748_41600.t6 VSS.t510 nfet_03v3 ad=2.6p pd=10.52u as=2.6p ps=10.52u w=10u l=0.28u
X756 XRX.XFRONT.XFE_O.VREGP.t5 O_REGEN_CLKB.t10 VDD.t324 VDD.t323 pfet_03v3 ad=2.08p pd=8.52u as=2.08p ps=8.52u w=8u l=0.28u
X757 VDD.t49 a_75604_31500.t0 VSS.t133 ppolyf_u r_width=2u r_length=4u
X758 FE_O_P.t2 XRX.XFRONT.XFE_O.BP.t20 VDD.t378 VDD.t377 pfet_03v3 ad=2.08p pd=8.52u as=2.08p ps=8.52u w=8u l=0.28u
X759 VDD.t18 a_484_3500.t0 VSS.t34 ppolyf_u r_width=1u r_length=1.4u
X760 a_2548_44200.t0 SAMP_E_P.t6 SAMP_E_N.t3 VSS.t121 nfet_03v3 ad=1.56p pd=6.52u as=2.64p ps=12.88u w=6u l=0.28u
X761 VDD.t136 SAMP_O_N.t2 VSS.t190 ppolyf_u r_width=2u r_length=5u
X762 VSS.t284 XRX.XFRONT.XFE_E.BP.t11 FE_E_N.t1 VSS.t283 nfet_03v3 ad=2.08p pd=8.52u as=2.08p ps=8.52u w=8u l=0.28u
X763 VSS.t279 XRX.XFRONT.XFE_E.XN.t41 XRX.XFRONT.XFE_E.SXN.t3 VSS.t278 nfet_03v3 ad=2.08p pd=8.52u as=3.52p ps=16.88u w=8u l=0.28u
X764 VDD.t361 E_CAPTURE_CLKB.t3 XRX.XCAP.E_PSET_TAIL.t8 VDD.t303 pfet_03v3 ad=2.08p pd=8.52u as=2.08p ps=8.52u w=8u l=0.28u
X765 XRX.XFRONT.XFE_E.SXN.t6 XRX.XFRONT.XFE_E.XN.t44 VDD.t414 VDD.t413 pfet_03v3 ad=2.08p pd=8.52u as=2.08p ps=8.52u w=8u l=0.28u
X766 XRX.XFRONT.XFE_E.XN.t27 E_REGEN_CLK.t25 XRX.XFRONT.XFE_E.XP.t20 VDD.t263 pfet_03v3 ad=2.08p pd=8.52u as=2.08p ps=8.52u w=8u l=0.28u
R0 TERM_EN0_N.n0 TERM_EN0_N.t1 139.688
R1 TERM_EN0_N.n0 TERM_EN0_N.t0 139.688
R2 TERM_EN0_N.n2 TERM_EN0_N.t3 62.9541
R3 TERM_EN0_N.n1 TERM_EN0_N.t2 49.9184
R4 TERM_EN0_N.n1 TERM_EN0_N.n0 22.445
R5 TERM_EN0_N.n2 TERM_EN0_N.n1 0.8735
R6 TERM_EN0_N TERM_EN0_N.n2 0.539857
R7 TERM_EN1_N.n0 TERM_EN1_N.t1 139.688
R8 TERM_EN1_N.n0 TERM_EN1_N.t0 139.688
R9 TERM_EN1_N.n2 TERM_EN1_N.t3 62.9541
R10 TERM_EN1_N.n1 TERM_EN1_N.t2 49.9184
R11 TERM_EN1_N.n1 TERM_EN1_N.n0 22.445
R12 TERM_EN1_N.n2 TERM_EN1_N.n1 0.8735
R13 TERM_EN1_N TERM_EN1_N.n2 0.539857
R14 TERM_EN2_N.n0 TERM_EN2_N.t1 139.688
R15 TERM_EN2_N.n0 TERM_EN2_N.t0 139.688
R16 TERM_EN2_N.n2 TERM_EN2_N.t3 62.9541
R17 TERM_EN2_N.n1 TERM_EN2_N.t2 49.9184
R18 TERM_EN2_N.n1 TERM_EN2_N.n0 22.445
R19 TERM_EN2_N.n2 TERM_EN2_N.n1 0.8735
R20 TERM_EN2_N TERM_EN2_N.n2 0.539857
R21 TERM_EN3_N.n0 TERM_EN3_N.t1 139.688
R22 TERM_EN3_N.n0 TERM_EN3_N.t0 139.688
R23 TERM_EN3_N.n2 TERM_EN3_N.t3 62.9541
R24 TERM_EN3_N.n1 TERM_EN3_N.t2 49.9184
R25 TERM_EN3_N.n1 TERM_EN3_N.n0 22.445
R26 TERM_EN3_N.n2 TERM_EN3_N.n1 0.8735
R27 TERM_EN3_N TERM_EN3_N.n2 0.539857
R28 TERM_EN4_N.n0 TERM_EN4_N.t1 139.688
R29 TERM_EN4_N.n0 TERM_EN4_N.t0 139.688
R30 TERM_EN4_N.n2 TERM_EN4_N.t3 62.9541
R31 TERM_EN4_N.n1 TERM_EN4_N.t2 49.9184
R32 TERM_EN4_N.n1 TERM_EN4_N.n0 22.445
R33 TERM_EN4_N.n2 TERM_EN4_N.n1 0.8735
R34 TERM_EN4_N TERM_EN4_N.n2 0.539857
R35 TERM_EN5_N.n0 TERM_EN5_N.t1 139.688
R36 TERM_EN5_N.n0 TERM_EN5_N.t0 139.688
R37 TERM_EN5_N.n2 TERM_EN5_N.t3 62.9541
R38 TERM_EN5_N.n1 TERM_EN5_N.t2 49.9184
R39 TERM_EN5_N.n1 TERM_EN5_N.n0 22.445
R40 TERM_EN5_N.n2 TERM_EN5_N.n1 0.8735
R41 TERM_EN5_N TERM_EN5_N.n2 0.539857
R42 TERM_EN6_N.n0 TERM_EN6_N.t1 139.688
R43 TERM_EN6_N.n0 TERM_EN6_N.t0 139.688
R44 TERM_EN6_N.n2 TERM_EN6_N.t3 62.9541
R45 TERM_EN6_N.n1 TERM_EN6_N.t2 49.9184
R46 TERM_EN6_N.n1 TERM_EN6_N.n0 22.445
R47 TERM_EN6_N.n2 TERM_EN6_N.n1 0.8735
R48 TERM_EN6_N TERM_EN6_N.n2 0.539857
R49 RXN.n0 RXN.t8 139.689
R50 RXN.n0 RXN.t9 139.689
R51 RXN.n1 RXN.n0 32.5563
R52 RXN.n2 RXN.t5 16.451
R53 RXN.n7 RXN.t1 15.7257
R54 RXN.n6 RXN.t2 15.7257
R55 RXN.n5 RXN.t7 15.7257
R56 RXN.n4 RXN.t3 15.7257
R57 RXN.n3 RXN.t0 15.7257
R58 RXN.n2 RXN.t4 15.641
R59 RXN.n1 RXN.t6 12.4583
R60 RXN.n3 RXN.n2 0.8105
R61 RXN.n4 RXN.n3 0.8105
R62 RXN.n5 RXN.n4 0.8105
R63 RXN.n6 RXN.n5 0.8105
R64 RXN.n7 RXN.n6 0.8105
R65 RXN RXN.n7 0.6305
R66 RXN RXN.n1 0.1805
R67 RXP.n0 RXP.t8 139.689
R68 RXP.n0 RXP.t9 139.689
R69 RXP.n1 RXP.n0 32.5563
R70 RXP.n2 RXP.t2 16.451
R71 RXP.n3 RXP.t1 15.7257
R72 RXP.n4 RXP.t6 15.7257
R73 RXP.n5 RXP.t3 15.7257
R74 RXP.n6 RXP.t5 15.7257
R75 RXP.n7 RXP.t4 15.7257
R76 RXP.n2 RXP.t0 15.641
R77 RXP.n1 RXP.t7 12.4583
R78 RXP.n3 RXP.n2 0.8105
R79 RXP.n4 RXP.n3 0.8105
R80 RXP.n5 RXP.n4 0.8105
R81 RXP.n6 RXP.n5 0.8105
R82 RXP.n7 RXP.n6 0.8105
R83 RXP RXP.n7 0.6305
R84 RXP RXP.n1 0.1805
R85 RX_BIAS.n4 RX_BIAS.t4 139.702
R86 RX_BIAS.n0 RX_BIAS.t0 139.702
R87 RX_BIAS.n15 RX_BIAS.t9 139.702
R88 RX_BIAS.n11 RX_BIAS.t5 139.702
R89 RX_BIAS.n1 RX_BIAS.t1 135.246
R90 RX_BIAS.n2 RX_BIAS.t2 135.246
R91 RX_BIAS.n3 RX_BIAS.t3 135.246
R92 RX_BIAS.n12 RX_BIAS.t6 135.246
R93 RX_BIAS.n13 RX_BIAS.t7 135.246
R94 RX_BIAS.n14 RX_BIAS.t8 135.246
R95 RX_BIAS.n6 RX_BIAS.t10 35.4171
R96 RX_BIAS.n9 RX_BIAS.t13 35.4171
R97 RX_BIAS.n7 RX_BIAS.t11 30.9603
R98 RX_BIAS.n8 RX_BIAS.t12 30.9603
R99 RX_BIAS.n17 RX_BIAS.n10 21.4384
R100 RX_BIAS.n18 RX_BIAS.n5 18.9479
R101 RX_BIAS.n5 RX_BIAS.n2 18.4942
R102 RX_BIAS.n16 RX_BIAS.n13 18.4942
R103 RX_BIAS.n17 RX_BIAS.n16 18.0005
R104 RX_BIAS.n8 RX_BIAS.n7 11.6805
R105 RX_BIAS.n2 RX_BIAS.n1 11.6805
R106 RX_BIAS.n3 RX_BIAS.n2 11.6805
R107 RX_BIAS.n13 RX_BIAS.n12 11.6805
R108 RX_BIAS.n14 RX_BIAS.n13 11.6805
R109 RX_BIAS RX_BIAS.n18 7.56892
R110 RX_BIAS.n5 RX_BIAS.n0 7.16487
R111 RX_BIAS.n5 RX_BIAS.n4 7.16487
R112 RX_BIAS.n16 RX_BIAS.n11 7.16487
R113 RX_BIAS.n16 RX_BIAS.n15 7.16487
R114 RX_BIAS.n10 RX_BIAS.n6 7.09873
R115 RX_BIAS.n10 RX_BIAS.n9 7.09873
R116 RX_BIAS.n7 RX_BIAS.n6 4.42851
R117 RX_BIAS.n9 RX_BIAS.n8 4.42851
R118 RX_BIAS.n1 RX_BIAS.n0 4.42851
R119 RX_BIAS.n4 RX_BIAS.n3 4.42851
R120 RX_BIAS.n12 RX_BIAS.n11 4.42851
R121 RX_BIAS.n15 RX_BIAS.n14 4.42851
R122 RX_BIAS.n18 RX_BIAS.n17 0.947868
R123 VTHN.n0 VTHN.t0 35.4171
R124 VTHN.n0 VTHN.t1 35.3883
R125 VTHN VTHN.n0 35.0111
R126 VTHP.n0 VTHP.t1 35.4171
R127 VTHP.n0 VTHP.t0 35.3883
R128 VTHP VTHP.n0 34.2271
R129 RX_BW_EN_N.n0 RX_BW_EN_N.t0 104.718
R130 RX_BW_EN_N.n2 RX_BW_EN_N.t3 102.35
R131 RX_BW_EN_N.n1 RX_BW_EN_N.t2 102.35
R132 RX_BW_EN_N.n0 RX_BW_EN_N.t1 102.35
R133 RX_BW_EN_N RX_BW_EN_N.n2 2.55971
R134 RX_BW_EN_N.n2 RX_BW_EN_N.n1 2.36892
R135 RX_BW_EN_N.n1 RX_BW_EN_N.n0 1.89524
R136 RX_RAWN.n0 RX_RAWN.t4 139.689
R137 RX_RAWN.n0 RX_RAWN.t5 139.689
R138 RX_RAWN RX_RAWN.n0 36.4661
R139 RX_RAWN.n3 RX_RAWN.t0 12.5711
R140 RX_RAWN.n2 RX_RAWN.t1 10.6142
R141 RX_RAWN RX_RAWN.n3 6.39524
R142 RX_RAWN.n1 RX_RAWN.t2 6.0676
R143 RX_RAWN.n1 RX_RAWN.t3 6.06436
R144 RX_RAWN.n2 RX_RAWN.n1 3.78254
R145 RX_RAWN.n3 RX_RAWN.n2 0.491409
R146 RX_RAWP.n0 RX_RAWP.t4 139.689
R147 RX_RAWP.n0 RX_RAWP.t5 139.689
R148 RX_RAWP RX_RAWP.n0 36.3761
R149 RX_RAWP.n3 RX_RAWP.t2 12.5711
R150 RX_RAWP.n2 RX_RAWP.t1 10.6142
R151 RX_RAWP RX_RAWP.n3 6.39524
R152 RX_RAWP.n1 RX_RAWP.t0 6.0676
R153 RX_RAWP.n1 RX_RAWP.t3 6.06436
R154 RX_RAWP.n2 RX_RAWP.n1 3.78254
R155 RX_RAWP.n3 RX_RAWP.n2 0.491409
R156 PI_CTRL_B.n0 PI_CTRL_B.t0 74.5242
R157 PI_CTRL_B.n3 PI_CTRL_B.t3 74.5242
R158 PI_CTRL_B.n1 PI_CTRL_B.t1 70.0675
R159 PI_CTRL_B.n2 PI_CTRL_B.t2 70.0675
R160 PI_CTRL_B PI_CTRL_B.n4 18.2966
R161 PI_CTRL_B.n2 PI_CTRL_B.n1 11.6805
R162 PI_CTRL_B.n4 PI_CTRL_B.n0 7.10487
R163 PI_CTRL_B.n4 PI_CTRL_B.n3 7.10487
R164 PI_CTRL_B.n1 PI_CTRL_B.n0 4.42851
R165 PI_CTRL_B.n3 PI_CTRL_B.n2 4.42851
R166 PI_CTRL_A.n0 PI_CTRL_A.t0 74.5242
R167 PI_CTRL_A.n3 PI_CTRL_A.t3 74.5242
R168 PI_CTRL_A.n1 PI_CTRL_A.t1 70.0675
R169 PI_CTRL_A.n2 PI_CTRL_A.t2 70.0675
R170 PI_CTRL_A PI_CTRL_A.n4 15.7505
R171 PI_CTRL_A.n2 PI_CTRL_A.n1 11.6805
R172 PI_CTRL_A.n4 PI_CTRL_A.n0 7.10487
R173 PI_CTRL_A.n4 PI_CTRL_A.n3 7.10487
R174 PI_CTRL_A.n1 PI_CTRL_A.n0 4.42851
R175 PI_CTRL_A.n3 PI_CTRL_A.n2 4.42851
R176 PI_BUF_BIAS.n0 PI_BUF_BIAS.t0 139.702
R177 PI_BUF_BIAS.n3 PI_BUF_BIAS.t3 139.702
R178 PI_BUF_BIAS.n1 PI_BUF_BIAS.t1 135.246
R179 PI_BUF_BIAS.n2 PI_BUF_BIAS.t2 135.246
R180 PI_BUF_BIAS PI_BUF_BIAS.n4 14.7439
R181 PI_BUF_BIAS.n2 PI_BUF_BIAS.n1 11.6805
R182 PI_BUF_BIAS.n4 PI_BUF_BIAS.n0 7.10487
R183 PI_BUF_BIAS.n4 PI_BUF_BIAS.n3 7.10487
R184 PI_BUF_BIAS.n1 PI_BUF_BIAS.n0 4.42851
R185 PI_BUF_BIAS.n3 PI_BUF_BIAS.n2 4.42851
R186 PHASE_A_N.n0 PHASE_A_N.t1 74.5104
R187 PHASE_A_N.n0 PHASE_A_N.t0 74.5104
R188 PHASE_A_N PHASE_A_N.n0 26.3041
R189 PHASE_B_N.n0 PHASE_B_N.t1 74.5104
R190 PHASE_B_N.n0 PHASE_B_N.t0 74.5104
R191 PHASE_B_N PHASE_B_N.n0 26.3041
R192 PHASE_B_P.n0 PHASE_B_P.t1 74.5104
R193 PHASE_B_P.n0 PHASE_B_P.t0 74.5104
R194 PHASE_B_P PHASE_B_P.n0 26.3041
R195 PHASE_A_P.n0 PHASE_A_P.t1 74.5104
R196 PHASE_A_P.n0 PHASE_A_P.t0 74.5104
R197 PHASE_A_P PHASE_A_P.n0 26.3041
R198 PI_RAW_N.n0 PI_RAW_N.t4 139.689
R199 PI_RAW_N.n0 PI_RAW_N.t3 139.689
R200 PI_RAW_N PI_RAW_N.n0 25.9298
R201 PI_RAW_N PI_RAW_N.n2 21.5831
R202 PI_RAW_N.n2 PI_RAW_N.t0 12.4637
R203 PI_RAW_N.n1 PI_RAW_N.t1 6.0676
R204 PI_RAW_N.n1 PI_RAW_N.t2 6.06436
R205 PI_RAW_N.n2 PI_RAW_N.n1 3.31209
R206 PI_RAW_P.n0 PI_RAW_P.t4 139.689
R207 PI_RAW_P.n0 PI_RAW_P.t3 139.689
R208 PI_RAW_P.n3 PI_RAW_P.n2 36.6078
R209 PI_RAW_P.n3 PI_RAW_P.n0 25.8876
R210 PI_RAW_P.n2 PI_RAW_P.t0 12.4637
R211 PI_RAW_P.n1 PI_RAW_P.t2 6.0676
R212 PI_RAW_P.n1 PI_RAW_P.t1 6.06436
R213 PI_RAW_P.n2 PI_RAW_P.n1 3.31209
R214 PI_RAW_P PI_RAW_P.n3 0.0426053
R215 REST_BIAS.n8 REST_BIAS.t3 165.774
R216 REST_BIAS.n5 REST_BIAS.t0 165.774
R217 REST_BIAS.n0 REST_BIAS.t4 165.774
R218 REST_BIAS.n3 REST_BIAS.t7 165.774
R219 REST_BIAS.n6 REST_BIAS.t1 161.317
R220 REST_BIAS.n7 REST_BIAS.t2 161.317
R221 REST_BIAS.n1 REST_BIAS.t5 161.317
R222 REST_BIAS.n2 REST_BIAS.t6 161.317
R223 REST_BIAS.n10 REST_BIAS.n4 19.0663
R224 REST_BIAS.n10 REST_BIAS.n9 13.5005
R225 REST_BIAS.n7 REST_BIAS.n6 11.6805
R226 REST_BIAS.n2 REST_BIAS.n1 11.6805
R227 REST_BIAS.n9 REST_BIAS.n5 7.10487
R228 REST_BIAS.n9 REST_BIAS.n8 7.10487
R229 REST_BIAS.n4 REST_BIAS.n0 7.10487
R230 REST_BIAS.n4 REST_BIAS.n3 7.10487
R231 REST_BIAS REST_BIAS.n10 6.38708
R232 REST_BIAS.n6 REST_BIAS.n5 4.42851
R233 REST_BIAS.n8 REST_BIAS.n7 4.42851
R234 REST_BIAS.n1 REST_BIAS.n0 4.42851
R235 REST_BIAS.n3 REST_BIAS.n2 4.42851
R236 CLK_REST_BIAS.n8 CLK_REST_BIAS.t3 165.774
R237 CLK_REST_BIAS.n5 CLK_REST_BIAS.t0 165.774
R238 CLK_REST_BIAS.n0 CLK_REST_BIAS.t4 165.774
R239 CLK_REST_BIAS.n3 CLK_REST_BIAS.t7 165.774
R240 CLK_REST_BIAS.n6 CLK_REST_BIAS.t1 161.317
R241 CLK_REST_BIAS.n7 CLK_REST_BIAS.t2 161.317
R242 CLK_REST_BIAS.n1 CLK_REST_BIAS.t5 161.317
R243 CLK_REST_BIAS.n2 CLK_REST_BIAS.t6 161.317
R244 CLK_REST_BIAS.n10 CLK_REST_BIAS.n4 19.0663
R245 CLK_REST_BIAS.n10 CLK_REST_BIAS.n9 13.5005
R246 CLK_REST_BIAS.n7 CLK_REST_BIAS.n6 11.6805
R247 CLK_REST_BIAS.n2 CLK_REST_BIAS.n1 11.6805
R248 CLK_REST_BIAS.n9 CLK_REST_BIAS.n5 7.10487
R249 CLK_REST_BIAS.n9 CLK_REST_BIAS.n8 7.10487
R250 CLK_REST_BIAS.n4 CLK_REST_BIAS.n0 7.10487
R251 CLK_REST_BIAS.n4 CLK_REST_BIAS.n3 7.10487
R252 CLK_REST_BIAS.n6 CLK_REST_BIAS.n5 4.42851
R253 CLK_REST_BIAS.n8 CLK_REST_BIAS.n7 4.42851
R254 CLK_REST_BIAS.n1 CLK_REST_BIAS.n0 4.42851
R255 CLK_REST_BIAS.n3 CLK_REST_BIAS.n2 4.42851
R256 CLK_REST_BIAS CLK_REST_BIAS.n10 0.250763
R257 SAMP_BIAS.n3 SAMP_BIAS.t3 139.702
R258 SAMP_BIAS.n0 SAMP_BIAS.t0 139.702
R259 SAMP_BIAS.n5 SAMP_BIAS.t4 139.702
R260 SAMP_BIAS.n8 SAMP_BIAS.t7 139.702
R261 SAMP_BIAS.n1 SAMP_BIAS.t1 135.246
R262 SAMP_BIAS.n2 SAMP_BIAS.t2 135.246
R263 SAMP_BIAS.n6 SAMP_BIAS.t5 135.246
R264 SAMP_BIAS.n7 SAMP_BIAS.t6 135.246
R265 SAMP_BIAS.n10 SAMP_BIAS.n4 19.1847
R266 SAMP_BIAS.n10 SAMP_BIAS.n9 13.5005
R267 SAMP_BIAS SAMP_BIAS.n10 12.8674
R268 SAMP_BIAS.n2 SAMP_BIAS.n1 11.6805
R269 SAMP_BIAS.n7 SAMP_BIAS.n6 11.6805
R270 SAMP_BIAS.n4 SAMP_BIAS.n0 7.10487
R271 SAMP_BIAS.n4 SAMP_BIAS.n3 7.10487
R272 SAMP_BIAS.n9 SAMP_BIAS.n5 7.10487
R273 SAMP_BIAS.n9 SAMP_BIAS.n8 7.10487
R274 SAMP_BIAS.n1 SAMP_BIAS.n0 4.42851
R275 SAMP_BIAS.n3 SAMP_BIAS.n2 4.42851
R276 SAMP_BIAS.n6 SAMP_BIAS.n5 4.42851
R277 SAMP_BIAS.n8 SAMP_BIAS.n7 4.42851
R278 PI_CLK_N.n0 PI_CLK_N.t5 113.618
R279 PI_CLK_N.n0 PI_CLK_N.t6 113.618
R280 PI_CLK_N.n1 PI_CLK_N.t3 113.618
R281 PI_CLK_N.n1 PI_CLK_N.t4 113.618
R282 PI_CLK_N.n2 PI_CLK_N.n1 25.1703
R283 PI_CLK_N.n2 PI_CLK_N.n0 20.9071
R284 PI_CLK_N PI_CLK_N.n4 17.198
R285 PI_CLK_N PI_CLK_N.n2 13.1737
R286 PI_CLK_N.n4 PI_CLK_N.t2 12.205
R287 PI_CLK_N.n3 PI_CLK_N.t0 6.0613
R288 PI_CLK_N.n3 PI_CLK_N.t1 6.0613
R289 PI_CLK_N.n4 PI_CLK_N.n3 2.97532
R290 PI_CLK_P.n0 PI_CLK_P.t5 113.618
R291 PI_CLK_P.n0 PI_CLK_P.t6 113.618
R292 PI_CLK_P.n1 PI_CLK_P.t3 113.618
R293 PI_CLK_P.n1 PI_CLK_P.t4 113.618
R294 PI_CLK_P.n2 PI_CLK_P.n1 28.3203
R295 PI_CLK_P.n2 PI_CLK_P.n0 25.1624
R296 PI_CLK_P PI_CLK_P.n4 20.0359
R297 PI_CLK_P.n4 PI_CLK_P.t0 12.205
R298 PI_CLK_P.n3 PI_CLK_P.t1 6.0613
R299 PI_CLK_P.n3 PI_CLK_P.t2 6.0613
R300 PI_CLK_P PI_CLK_P.n2 5.7105
R301 PI_CLK_P.n4 PI_CLK_P.n3 2.95032
R302 RX_RESTP.n1 RX_RESTP.t5 87.5461
R303 RX_RESTP.n1 RX_RESTP.t6 87.5461
R304 RX_RESTP.n0 RX_RESTP.t3 87.5461
R305 RX_RESTP.n0 RX_RESTP.t4 87.5461
R306 RX_RESTP.n2 RX_RESTP.n0 31.2488
R307 RX_RESTP.n2 RX_RESTP.n1 25.5646
R308 RX_RESTP RX_RESTP.n2 14.1979
R309 RX_RESTP.n4 RX_RESTP.t0 12.57
R310 RX_RESTP RX_RESTP.n4 11.8991
R311 RX_RESTP.n3 RX_RESTP.t1 6.0613
R312 RX_RESTP.n3 RX_RESTP.t2 6.0613
R313 RX_RESTP.n4 RX_RESTP.n3 2.77532
R314 RX_RESTN.n0 RX_RESTN.t5 87.5461
R315 RX_RESTN.n0 RX_RESTN.t6 87.5461
R316 RX_RESTN.n1 RX_RESTN.t3 87.5461
R317 RX_RESTN.n1 RX_RESTN.t4 87.5461
R318 RX_RESTN.n2 RX_RESTN.n1 22.0262
R319 RX_RESTN.n2 RX_RESTN.n0 16.342
R320 RX_RESTN.n4 RX_RESTN.t0 12.57
R321 RX_RESTN RX_RESTN.n4 9.30958
R322 RX_RESTN RX_RESTN.n2 9.17813
R323 RX_RESTN.n3 RX_RESTN.t1 6.0613
R324 RX_RESTN.n3 RX_RESTN.t2 6.0613
R325 RX_RESTN.n4 RX_RESTN.n3 2.77532
R326 O_SENSE_BOOST.n3 O_SENSE_BOOST.t5 113.632
R327 O_SENSE_BOOST.n0 O_SENSE_BOOST.t0 109.174
R328 O_SENSE_BOOST.n7 O_SENSE_BOOST.t1 109.174
R329 O_SENSE_BOOST.n6 O_SENSE_BOOST.t2 109.174
R330 O_SENSE_BOOST.n5 O_SENSE_BOOST.t3 109.174
R331 O_SENSE_BOOST.n2 O_SENSE_BOOST.t4 109.174
R332 O_SENSE_BOOST O_SENSE_BOOST.n9 34.2009
R333 O_SENSE_BOOST.n9 O_SENSE_BOOST.n0 18.5636
R334 O_SENSE_BOOST.n8 O_SENSE_BOOST.n7 18.4942
R335 O_SENSE_BOOST.n6 O_SENSE_BOOST.n1 18.4942
R336 O_SENSE_BOOST.n5 O_SENSE_BOOST.n4 18.4942
R337 O_SENSE_BOOST.n7 O_SENSE_BOOST.n0 11.6805
R338 O_SENSE_BOOST.n7 O_SENSE_BOOST.n6 11.6805
R339 O_SENSE_BOOST.n6 O_SENSE_BOOST.n5 11.6805
R340 O_SENSE_BOOST.n5 O_SENSE_BOOST.n2 11.6805
R341 O_SENSE_BOOST.n4 O_SENSE_BOOST.n3 7.17687
R342 O_SENSE_BOOST.n3 O_SENSE_BOOST.n2 4.42851
R343 O_SENSE_BOOST.n4 O_SENSE_BOOST.n1 0.1205
R344 O_SENSE_BOOST.n8 O_SENSE_BOOST.n1 0.1205
R345 O_SENSE_BOOST.n9 O_SENSE_BOOST.n8 0.0485
R346 SAMP_O_N.n10 SAMP_O_N.t7 113.618
R347 SAMP_O_N.n10 SAMP_O_N.t8 113.618
R348 SAMP_O_N.n1 SAMP_O_N.t5 87.5461
R349 SAMP_O_N.n1 SAMP_O_N.t6 87.5461
R350 SAMP_O_N SAMP_O_N.n10 54.516
R351 SAMP_O_N.n2 SAMP_O_N.n1 26.3217
R352 SAMP_O_N SAMP_O_N.n9 14.2502
R353 SAMP_O_N.n9 SAMP_O_N.t2 12.4596
R354 SAMP_O_N.n0 SAMP_O_N.t0 5.96544
R355 SAMP_O_N.n0 SAMP_O_N.t1 5.9622
R356 SAMP_O_N.n5 SAMP_O_N.t4 5.87051
R357 SAMP_O_N.n4 SAMP_O_N.t3 5.87051
R358 SAMP_O_N.n4 SAMP_O_N.n3 4.5005
R359 SAMP_O_N.n6 SAMP_O_N.n5 4.5005
R360 SAMP_O_N.n8 SAMP_O_N.n0 2.56391
R361 SAMP_O_N.n9 SAMP_O_N.n8 0.8805
R362 SAMP_O_N.n7 SAMP_O_N.n2 0.419
R363 SAMP_O_N.n8 SAMP_O_N.n7 0.2415
R364 SAMP_O_N.n5 SAMP_O_N.n4 0.189974
R365 SAMP_O_N.n6 SAMP_O_N.n3 0.1605
R366 SAMP_O_N.n7 SAMP_O_N.n6 0.0795
R367 SAMP_O_N.n3 SAMP_O_N.n2 0.0740593
R368 SAMP_O_P.n10 SAMP_O_P.t7 113.618
R369 SAMP_O_P.n10 SAMP_O_P.t8 113.618
R370 SAMP_O_P.n0 SAMP_O_P.t5 87.5461
R371 SAMP_O_P.n0 SAMP_O_P.t6 87.5461
R372 SAMP_O_P SAMP_O_P.n10 49.414
R373 SAMP_O_P.n1 SAMP_O_P.n0 35.3132
R374 SAMP_O_P SAMP_O_P.n9 14.2502
R375 SAMP_O_P.n9 SAMP_O_P.t2 12.4596
R376 SAMP_O_P.n7 SAMP_O_P.t1 5.96544
R377 SAMP_O_P.n7 SAMP_O_P.t0 5.9622
R378 SAMP_O_P.n3 SAMP_O_P.t3 5.87051
R379 SAMP_O_P.n4 SAMP_O_P.t4 5.87051
R380 SAMP_O_P.n5 SAMP_O_P.n4 4.5005
R381 SAMP_O_P.n3 SAMP_O_P.n2 4.5005
R382 SAMP_O_P.n8 SAMP_O_P.n7 2.56391
R383 SAMP_O_P.n9 SAMP_O_P.n8 0.8805
R384 SAMP_O_P.n6 SAMP_O_P.n1 0.419
R385 SAMP_O_P.n8 SAMP_O_P.n6 0.2415
R386 SAMP_O_P.n4 SAMP_O_P.n3 0.189974
R387 SAMP_O_P.n5 SAMP_O_P.n2 0.1605
R388 SAMP_O_P.n6 SAMP_O_P.n5 0.0795
R389 SAMP_O_P.n2 SAMP_O_P.n1 0.0405
R390 E_SENSE_BOOST.n3 E_SENSE_BOOST.t0 113.632
R391 E_SENSE_BOOST.n4 E_SENSE_BOOST.t1 109.174
R392 E_SENSE_BOOST.n5 E_SENSE_BOOST.t2 109.174
R393 E_SENSE_BOOST.n6 E_SENSE_BOOST.t3 109.174
R394 E_SENSE_BOOST.n7 E_SENSE_BOOST.t4 109.174
R395 E_SENSE_BOOST.n8 E_SENSE_BOOST.t5 109.174
R396 E_SENSE_BOOST E_SENSE_BOOST.n9 34.2009
R397 E_SENSE_BOOST.n9 E_SENSE_BOOST.n8 18.5636
R398 E_SENSE_BOOST.n5 E_SENSE_BOOST.n2 18.4942
R399 E_SENSE_BOOST.n6 E_SENSE_BOOST.n1 18.4942
R400 E_SENSE_BOOST.n7 E_SENSE_BOOST.n0 18.4942
R401 E_SENSE_BOOST.n5 E_SENSE_BOOST.n4 11.6805
R402 E_SENSE_BOOST.n6 E_SENSE_BOOST.n5 11.6805
R403 E_SENSE_BOOST.n7 E_SENSE_BOOST.n6 11.6805
R404 E_SENSE_BOOST.n8 E_SENSE_BOOST.n7 11.6805
R405 E_SENSE_BOOST.n3 E_SENSE_BOOST.n2 7.17687
R406 E_SENSE_BOOST.n4 E_SENSE_BOOST.n3 4.42851
R407 E_SENSE_BOOST.n1 E_SENSE_BOOST.n0 0.1205
R408 E_SENSE_BOOST.n2 E_SENSE_BOOST.n1 0.1205
R409 E_SENSE_BOOST.n9 E_SENSE_BOOST.n0 0.0485
R410 SAMP_E_N.n10 SAMP_E_N.t7 113.618
R411 SAMP_E_N.n10 SAMP_E_N.t8 113.618
R412 SAMP_E_N.n1 SAMP_E_N.t5 87.5461
R413 SAMP_E_N.n1 SAMP_E_N.t6 87.5461
R414 SAMP_E_N SAMP_E_N.n10 49.414
R415 SAMP_E_N.n2 SAMP_E_N.n1 26.3484
R416 SAMP_E_N SAMP_E_N.n9 14.2502
R417 SAMP_E_N.n9 SAMP_E_N.t2 12.4596
R418 SAMP_E_N.n0 SAMP_E_N.t1 5.96544
R419 SAMP_E_N.n0 SAMP_E_N.t0 5.9622
R420 SAMP_E_N.n5 SAMP_E_N.t4 5.87051
R421 SAMP_E_N.n4 SAMP_E_N.t3 5.87051
R422 SAMP_E_N.n4 SAMP_E_N.n3 4.5005
R423 SAMP_E_N.n6 SAMP_E_N.n5 4.5005
R424 SAMP_E_N.n8 SAMP_E_N.n0 2.56391
R425 SAMP_E_N.n9 SAMP_E_N.n8 0.8805
R426 SAMP_E_N.n7 SAMP_E_N.n2 0.419
R427 SAMP_E_N.n8 SAMP_E_N.n7 0.2415
R428 SAMP_E_N.n5 SAMP_E_N.n4 0.189974
R429 SAMP_E_N.n6 SAMP_E_N.n3 0.1605
R430 SAMP_E_N.n7 SAMP_E_N.n6 0.0795
R431 SAMP_E_N.n3 SAMP_E_N.n2 0.0405
R432 SAMP_E_P.n10 SAMP_E_P.t7 113.618
R433 SAMP_E_P.n10 SAMP_E_P.t8 113.618
R434 SAMP_E_P.n0 SAMP_E_P.t5 87.5461
R435 SAMP_E_P.n0 SAMP_E_P.t6 87.5461
R436 SAMP_E_P SAMP_E_P.n10 54.516
R437 SAMP_E_P.n1 SAMP_E_P.n0 35.155
R438 SAMP_E_P SAMP_E_P.n9 14.2502
R439 SAMP_E_P.n9 SAMP_E_P.t4 12.4596
R440 SAMP_E_P.n7 SAMP_E_P.t1 5.96544
R441 SAMP_E_P.n7 SAMP_E_P.t0 5.9622
R442 SAMP_E_P.n3 SAMP_E_P.t2 5.87051
R443 SAMP_E_P.n4 SAMP_E_P.t3 5.87051
R444 SAMP_E_P.n5 SAMP_E_P.n4 4.5005
R445 SAMP_E_P.n3 SAMP_E_P.n2 4.5005
R446 SAMP_E_P.n8 SAMP_E_P.n7 2.56391
R447 SAMP_E_P.n9 SAMP_E_P.n8 0.8805
R448 SAMP_E_P.n6 SAMP_E_P.n1 0.419
R449 SAMP_E_P.n8 SAMP_E_P.n6 0.2415
R450 SAMP_E_P.n4 SAMP_E_P.n3 0.189974
R451 SAMP_E_P.n5 SAMP_E_P.n2 0.1605
R452 SAMP_E_P.n6 SAMP_E_P.n5 0.0795
R453 SAMP_E_P.n2 SAMP_E_P.n1 0.0740593
R454 O_SENSE_CLK.n0 O_SENSE_CLK.t2 113.632
R455 O_SENSE_CLK.n1 O_SENSE_CLK.t5 113.632
R456 O_SENSE_CLK.n5 O_SENSE_CLK.t6 113.632
R457 O_SENSE_CLK.n3 O_SENSE_CLK.t0 113.618
R458 O_SENSE_CLK.n3 O_SENSE_CLK.t1 113.618
R459 O_SENSE_CLK.n0 O_SENSE_CLK.t3 113.603
R460 O_SENSE_CLK.n1 O_SENSE_CLK.t4 113.603
R461 O_SENSE_CLK.n5 O_SENSE_CLK.t7 113.603
R462 O_SENSE_CLK.n6 O_SENSE_CLK.n5 35.4506
R463 O_SENSE_CLK.n4 O_SENSE_CLK.n2 22.7641
R464 O_SENSE_CLK O_SENSE_CLK.n6 18.6466
R465 O_SENSE_CLK.n4 O_SENSE_CLK.n3 16.0613
R466 O_SENSE_CLK.n6 O_SENSE_CLK.n4 9.38566
R467 O_SENSE_CLK.n2 O_SENSE_CLK.n0 7.88487
R468 O_SENSE_CLK.n2 O_SENSE_CLK.n1 7.88487
R469 E_SENSE_CLK.n5 E_SENSE_CLK.t3 113.632
R470 E_SENSE_CLK.n0 E_SENSE_CLK.t4 113.632
R471 E_SENSE_CLK.n1 E_SENSE_CLK.t7 113.632
R472 E_SENSE_CLK.n3 E_SENSE_CLK.t0 113.618
R473 E_SENSE_CLK.n3 E_SENSE_CLK.t1 113.618
R474 E_SENSE_CLK.n5 E_SENSE_CLK.t2 113.603
R475 E_SENSE_CLK.n0 E_SENSE_CLK.t5 113.603
R476 E_SENSE_CLK.n1 E_SENSE_CLK.t6 113.603
R477 E_SENSE_CLK.n6 E_SENSE_CLK.n5 35.4506
R478 E_SENSE_CLK.n4 E_SENSE_CLK.n2 22.7641
R479 E_SENSE_CLK E_SENSE_CLK.n6 18.6466
R480 E_SENSE_CLK.n4 E_SENSE_CLK.n3 16.0613
R481 E_SENSE_CLK.n6 E_SENSE_CLK.n4 9.38566
R482 E_SENSE_CLK.n2 E_SENSE_CLK.n0 7.88487
R483 E_SENSE_CLK.n2 E_SENSE_CLK.n1 7.88487
R484 O_REGEN_CLK.t12 O_REGEN_CLK.n72 127.788
R485 O_REGEN_CLK.t35 O_REGEN_CLK.n32 127.788
R486 O_REGEN_CLK.t20 O_REGEN_CLK.n11 127.788
R487 O_REGEN_CLK.t19 O_REGEN_CLK.n61 127.668
R488 O_REGEN_CLK.n72 O_REGEN_CLK.t13 127.668
R489 O_REGEN_CLK.n71 O_REGEN_CLK.t14 127.668
R490 O_REGEN_CLK.n70 O_REGEN_CLK.t15 127.668
R491 O_REGEN_CLK.n69 O_REGEN_CLK.t16 127.668
R492 O_REGEN_CLK.n68 O_REGEN_CLK.t17 127.668
R493 O_REGEN_CLK.n67 O_REGEN_CLK.t18 127.668
R494 O_REGEN_CLK.t27 O_REGEN_CLK.n20 127.668
R495 O_REGEN_CLK.t28 O_REGEN_CLK.n41 127.668
R496 O_REGEN_CLK.n40 O_REGEN_CLK.t29 127.668
R497 O_REGEN_CLK.n32 O_REGEN_CLK.t34 127.668
R498 O_REGEN_CLK.n31 O_REGEN_CLK.t33 127.668
R499 O_REGEN_CLK.n30 O_REGEN_CLK.t32 127.668
R500 O_REGEN_CLK.t31 O_REGEN_CLK.n25 127.668
R501 O_REGEN_CLK.n39 O_REGEN_CLK.t30 127.668
R502 O_REGEN_CLK.n11 O_REGEN_CLK.t21 127.668
R503 O_REGEN_CLK.n10 O_REGEN_CLK.t22 127.668
R504 O_REGEN_CLK.n9 O_REGEN_CLK.t23 127.668
R505 O_REGEN_CLK.t24 O_REGEN_CLK.n4 127.668
R506 O_REGEN_CLK.n18 O_REGEN_CLK.t25 127.668
R507 O_REGEN_CLK.n19 O_REGEN_CLK.t26 127.668
R508 O_REGEN_CLK.n84 O_REGEN_CLK.t8 113.632
R509 O_REGEN_CLK.n0 O_REGEN_CLK.t10 113.632
R510 O_REGEN_CLK.n73 O_REGEN_CLK.t12 113.632
R511 O_REGEN_CLK.n48 O_REGEN_CLK.t7 113.632
R512 O_REGEN_CLK.n52 O_REGEN_CLK.t0 113.632
R513 O_REGEN_CLK.n33 O_REGEN_CLK.t35 113.632
R514 O_REGEN_CLK.n12 O_REGEN_CLK.t20 113.632
R515 O_REGEN_CLK.n84 O_REGEN_CLK.t9 113.603
R516 O_REGEN_CLK.n0 O_REGEN_CLK.t11 113.603
R517 O_REGEN_CLK.n80 O_REGEN_CLK.t19 109.174
R518 O_REGEN_CLK.n74 O_REGEN_CLK.t13 109.174
R519 O_REGEN_CLK.n75 O_REGEN_CLK.t14 109.174
R520 O_REGEN_CLK.n76 O_REGEN_CLK.t15 109.174
R521 O_REGEN_CLK.n77 O_REGEN_CLK.t16 109.174
R522 O_REGEN_CLK.n78 O_REGEN_CLK.t17 109.174
R523 O_REGEN_CLK.n79 O_REGEN_CLK.t18 109.174
R524 O_REGEN_CLK.n55 O_REGEN_CLK.t3 109.174
R525 O_REGEN_CLK.n56 O_REGEN_CLK.t4 109.174
R526 O_REGEN_CLK.n49 O_REGEN_CLK.t6 109.174
R527 O_REGEN_CLK.n50 O_REGEN_CLK.t5 109.174
R528 O_REGEN_CLK.n54 O_REGEN_CLK.t2 109.174
R529 O_REGEN_CLK.n51 O_REGEN_CLK.t1 109.174
R530 O_REGEN_CLK.n21 O_REGEN_CLK.t27 109.174
R531 O_REGEN_CLK.n42 O_REGEN_CLK.t28 109.174
R532 O_REGEN_CLK.t29 O_REGEN_CLK.n24 109.174
R533 O_REGEN_CLK.n34 O_REGEN_CLK.t34 109.174
R534 O_REGEN_CLK.n35 O_REGEN_CLK.t33 109.174
R535 O_REGEN_CLK.n36 O_REGEN_CLK.t32 109.174
R536 O_REGEN_CLK.n37 O_REGEN_CLK.t31 109.174
R537 O_REGEN_CLK.t30 O_REGEN_CLK.n38 109.174
R538 O_REGEN_CLK.n13 O_REGEN_CLK.t21 109.174
R539 O_REGEN_CLK.n14 O_REGEN_CLK.t22 109.174
R540 O_REGEN_CLK.n15 O_REGEN_CLK.t23 109.174
R541 O_REGEN_CLK.n16 O_REGEN_CLK.t24 109.174
R542 O_REGEN_CLK.t25 O_REGEN_CLK.n17 109.174
R543 O_REGEN_CLK.t26 O_REGEN_CLK.n3 109.174
R544 O_REGEN_CLK.n60 O_REGEN_CLK.n0 27.7007
R545 O_REGEN_CLK.n85 O_REGEN_CLK.n84 22.692
R546 O_REGEN_CLK.n59 O_REGEN_CLK.n58 20.0962
R547 O_REGEN_CLK.n81 O_REGEN_CLK.n80 18.4942
R548 O_REGEN_CLK.n75 O_REGEN_CLK.n66 18.4942
R549 O_REGEN_CLK.n76 O_REGEN_CLK.n65 18.4942
R550 O_REGEN_CLK.n77 O_REGEN_CLK.n64 18.4942
R551 O_REGEN_CLK.n78 O_REGEN_CLK.n63 18.4942
R552 O_REGEN_CLK.n79 O_REGEN_CLK.n62 18.4942
R553 O_REGEN_CLK.n55 O_REGEN_CLK.n46 18.4942
R554 O_REGEN_CLK.n57 O_REGEN_CLK.n56 18.4942
R555 O_REGEN_CLK.n50 O_REGEN_CLK.n47 18.4942
R556 O_REGEN_CLK.n54 O_REGEN_CLK.n53 18.4942
R557 O_REGEN_CLK.n22 O_REGEN_CLK.n21 18.4942
R558 O_REGEN_CLK.n43 O_REGEN_CLK.n42 18.4942
R559 O_REGEN_CLK.n24 O_REGEN_CLK.n23 18.4942
R560 O_REGEN_CLK.n35 O_REGEN_CLK.n29 18.4942
R561 O_REGEN_CLK.n36 O_REGEN_CLK.n28 18.4942
R562 O_REGEN_CLK.n37 O_REGEN_CLK.n27 18.4942
R563 O_REGEN_CLK.n38 O_REGEN_CLK.n26 18.4942
R564 O_REGEN_CLK.n14 O_REGEN_CLK.n8 18.4942
R565 O_REGEN_CLK.n15 O_REGEN_CLK.n7 18.4942
R566 O_REGEN_CLK.n16 O_REGEN_CLK.n6 18.4942
R567 O_REGEN_CLK.n17 O_REGEN_CLK.n5 18.4942
R568 O_REGEN_CLK.n3 O_REGEN_CLK.n2 18.4942
R569 O_REGEN_CLK O_REGEN_CLK.n85 15.9857
R570 O_REGEN_CLK.n75 O_REGEN_CLK.n74 11.6805
R571 O_REGEN_CLK.n76 O_REGEN_CLK.n75 11.6805
R572 O_REGEN_CLK.n77 O_REGEN_CLK.n76 11.6805
R573 O_REGEN_CLK.n78 O_REGEN_CLK.n77 11.6805
R574 O_REGEN_CLK.n79 O_REGEN_CLK.n78 11.6805
R575 O_REGEN_CLK.n80 O_REGEN_CLK.n79 11.6805
R576 O_REGEN_CLK.n55 O_REGEN_CLK.n54 11.6805
R577 O_REGEN_CLK.n56 O_REGEN_CLK.n55 11.6805
R578 O_REGEN_CLK.n50 O_REGEN_CLK.n49 11.6805
R579 O_REGEN_CLK.n56 O_REGEN_CLK.n50 11.6805
R580 O_REGEN_CLK.n54 O_REGEN_CLK.n51 11.6805
R581 O_REGEN_CLK.n42 O_REGEN_CLK.n24 11.6805
R582 O_REGEN_CLK.n35 O_REGEN_CLK.n34 11.6805
R583 O_REGEN_CLK.n36 O_REGEN_CLK.n35 11.6805
R584 O_REGEN_CLK.n37 O_REGEN_CLK.n36 11.6805
R585 O_REGEN_CLK.n38 O_REGEN_CLK.n37 11.6805
R586 O_REGEN_CLK.n38 O_REGEN_CLK.n24 11.6805
R587 O_REGEN_CLK.n14 O_REGEN_CLK.n13 11.6805
R588 O_REGEN_CLK.n15 O_REGEN_CLK.n14 11.6805
R589 O_REGEN_CLK.n16 O_REGEN_CLK.n15 11.6805
R590 O_REGEN_CLK.n17 O_REGEN_CLK.n16 11.6805
R591 O_REGEN_CLK.n17 O_REGEN_CLK.n3 11.6805
R592 O_REGEN_CLK.n21 O_REGEN_CLK.n3 11.6805
R593 O_REGEN_CLK.n82 O_REGEN_CLK.n61 10.8876
R594 O_REGEN_CLK.n45 O_REGEN_CLK.n1 10.8396
R595 O_REGEN_CLK.n83 O_REGEN_CLK.n82 10.3248
R596 O_REGEN_CLK.n82 O_REGEN_CLK.n81 9.0485
R597 O_REGEN_CLK.n45 O_REGEN_CLK.n44 9.0005
R598 O_REGEN_CLK.n73 O_REGEN_CLK.n66 7.17687
R599 O_REGEN_CLK.n53 O_REGEN_CLK.n52 7.17687
R600 O_REGEN_CLK.n48 O_REGEN_CLK.n47 7.17687
R601 O_REGEN_CLK.n33 O_REGEN_CLK.n29 7.17687
R602 O_REGEN_CLK.n12 O_REGEN_CLK.n8 7.17687
R603 O_REGEN_CLK.n59 O_REGEN_CLK.n45 5.82479
R604 O_REGEN_CLK.n60 O_REGEN_CLK.n59 4.5005
R605 O_REGEN_CLK.n74 O_REGEN_CLK.n73 4.42851
R606 O_REGEN_CLK.n49 O_REGEN_CLK.n48 4.42851
R607 O_REGEN_CLK.n52 O_REGEN_CLK.n51 4.42851
R608 O_REGEN_CLK.n34 O_REGEN_CLK.n33 4.42851
R609 O_REGEN_CLK.n13 O_REGEN_CLK.n12 4.42851
R610 O_REGEN_CLK.n85 O_REGEN_CLK.n83 3.83528
R611 O_REGEN_CLK.n83 O_REGEN_CLK.n60 2.89615
R612 O_REGEN_CLK.n44 O_REGEN_CLK.n22 0.4685
R613 O_REGEN_CLK.n20 O_REGEN_CLK.n1 0.4685
R614 O_REGEN_CLK.n41 O_REGEN_CLK.n1 0.4685
R615 O_REGEN_CLK.n44 O_REGEN_CLK.n43 0.4685
R616 O_REGEN_CLK.n81 O_REGEN_CLK.n62 0.1205
R617 O_REGEN_CLK.n63 O_REGEN_CLK.n62 0.1205
R618 O_REGEN_CLK.n64 O_REGEN_CLK.n63 0.1205
R619 O_REGEN_CLK.n65 O_REGEN_CLK.n64 0.1205
R620 O_REGEN_CLK.n66 O_REGEN_CLK.n65 0.1205
R621 O_REGEN_CLK.n67 O_REGEN_CLK.n61 0.1205
R622 O_REGEN_CLK.n68 O_REGEN_CLK.n67 0.1205
R623 O_REGEN_CLK.n69 O_REGEN_CLK.n68 0.1205
R624 O_REGEN_CLK.n70 O_REGEN_CLK.n69 0.1205
R625 O_REGEN_CLK.n71 O_REGEN_CLK.n70 0.1205
R626 O_REGEN_CLK.n72 O_REGEN_CLK.n71 0.1205
R627 O_REGEN_CLK.n53 O_REGEN_CLK.n46 0.1205
R628 O_REGEN_CLK.n57 O_REGEN_CLK.n47 0.1205
R629 O_REGEN_CLK.n22 O_REGEN_CLK.n2 0.1205
R630 O_REGEN_CLK.n5 O_REGEN_CLK.n2 0.1205
R631 O_REGEN_CLK.n6 O_REGEN_CLK.n5 0.1205
R632 O_REGEN_CLK.n7 O_REGEN_CLK.n6 0.1205
R633 O_REGEN_CLK.n8 O_REGEN_CLK.n7 0.1205
R634 O_REGEN_CLK.n20 O_REGEN_CLK.n19 0.1205
R635 O_REGEN_CLK.n19 O_REGEN_CLK.n18 0.1205
R636 O_REGEN_CLK.n18 O_REGEN_CLK.n4 0.1205
R637 O_REGEN_CLK.n9 O_REGEN_CLK.n4 0.1205
R638 O_REGEN_CLK.n10 O_REGEN_CLK.n9 0.1205
R639 O_REGEN_CLK.n11 O_REGEN_CLK.n10 0.1205
R640 O_REGEN_CLK.n32 O_REGEN_CLK.n31 0.1205
R641 O_REGEN_CLK.n31 O_REGEN_CLK.n30 0.1205
R642 O_REGEN_CLK.n30 O_REGEN_CLK.n25 0.1205
R643 O_REGEN_CLK.n39 O_REGEN_CLK.n25 0.1205
R644 O_REGEN_CLK.n40 O_REGEN_CLK.n39 0.1205
R645 O_REGEN_CLK.n41 O_REGEN_CLK.n40 0.1205
R646 O_REGEN_CLK.n29 O_REGEN_CLK.n28 0.1205
R647 O_REGEN_CLK.n28 O_REGEN_CLK.n27 0.1205
R648 O_REGEN_CLK.n27 O_REGEN_CLK.n26 0.1205
R649 O_REGEN_CLK.n26 O_REGEN_CLK.n23 0.1205
R650 O_REGEN_CLK.n43 O_REGEN_CLK.n23 0.1205
R651 O_REGEN_CLK.n58 O_REGEN_CLK.n46 0.0485
R652 O_REGEN_CLK.n58 O_REGEN_CLK.n57 0.0485
R653 E_REGEN_CLK.t27 E_REGEN_CLK.n34 127.788
R654 E_REGEN_CLK.t12 E_REGEN_CLK.n11 127.788
R655 E_REGEN_CLK.n69 E_REGEN_CLK.t35 127.788
R656 E_REGEN_CLK.t19 E_REGEN_CLK.n20 127.668
R657 E_REGEN_CLK.n34 E_REGEN_CLK.t26 127.668
R658 E_REGEN_CLK.n33 E_REGEN_CLK.t25 127.668
R659 E_REGEN_CLK.n32 E_REGEN_CLK.t24 127.668
R660 E_REGEN_CLK.n31 E_REGEN_CLK.t23 127.668
R661 E_REGEN_CLK.n30 E_REGEN_CLK.t22 127.668
R662 E_REGEN_CLK.n29 E_REGEN_CLK.t21 127.668
R663 E_REGEN_CLK.n28 E_REGEN_CLK.t20 127.668
R664 E_REGEN_CLK.n11 E_REGEN_CLK.t13 127.668
R665 E_REGEN_CLK.n10 E_REGEN_CLK.t14 127.668
R666 E_REGEN_CLK.n9 E_REGEN_CLK.t15 127.668
R667 E_REGEN_CLK.t16 E_REGEN_CLK.n4 127.668
R668 E_REGEN_CLK.n18 E_REGEN_CLK.t17 127.668
R669 E_REGEN_CLK.n19 E_REGEN_CLK.t18 127.668
R670 E_REGEN_CLK.t28 E_REGEN_CLK.n61 127.668
R671 E_REGEN_CLK.t29 E_REGEN_CLK.n78 127.668
R672 E_REGEN_CLK.n77 E_REGEN_CLK.t30 127.668
R673 E_REGEN_CLK.n76 E_REGEN_CLK.t31 127.668
R674 E_REGEN_CLK.t32 E_REGEN_CLK.n64 127.668
R675 E_REGEN_CLK.t33 E_REGEN_CLK.n70 127.668
R676 E_REGEN_CLK.n69 E_REGEN_CLK.t34 127.668
R677 E_REGEN_CLK.n0 E_REGEN_CLK.t9 113.632
R678 E_REGEN_CLK.n84 E_REGEN_CLK.t11 113.632
R679 E_REGEN_CLK.n48 E_REGEN_CLK.t7 113.632
R680 E_REGEN_CLK.n52 E_REGEN_CLK.t0 113.632
R681 E_REGEN_CLK.n35 E_REGEN_CLK.t27 113.632
R682 E_REGEN_CLK.n12 E_REGEN_CLK.t12 113.632
R683 E_REGEN_CLK.t35 E_REGEN_CLK.n67 113.632
R684 E_REGEN_CLK.n0 E_REGEN_CLK.t8 113.603
R685 E_REGEN_CLK.n84 E_REGEN_CLK.t10 113.603
R686 E_REGEN_CLK.n55 E_REGEN_CLK.t3 109.174
R687 E_REGEN_CLK.n56 E_REGEN_CLK.t4 109.174
R688 E_REGEN_CLK.n49 E_REGEN_CLK.t6 109.174
R689 E_REGEN_CLK.n50 E_REGEN_CLK.t5 109.174
R690 E_REGEN_CLK.n54 E_REGEN_CLK.t2 109.174
R691 E_REGEN_CLK.n51 E_REGEN_CLK.t1 109.174
R692 E_REGEN_CLK.n21 E_REGEN_CLK.t19 109.174
R693 E_REGEN_CLK.t26 E_REGEN_CLK.n27 109.174
R694 E_REGEN_CLK.n37 E_REGEN_CLK.t25 109.174
R695 E_REGEN_CLK.n38 E_REGEN_CLK.t24 109.174
R696 E_REGEN_CLK.n39 E_REGEN_CLK.t23 109.174
R697 E_REGEN_CLK.n40 E_REGEN_CLK.t22 109.174
R698 E_REGEN_CLK.n41 E_REGEN_CLK.t21 109.174
R699 E_REGEN_CLK.n42 E_REGEN_CLK.t20 109.174
R700 E_REGEN_CLK.n13 E_REGEN_CLK.t13 109.174
R701 E_REGEN_CLK.n14 E_REGEN_CLK.t14 109.174
R702 E_REGEN_CLK.n15 E_REGEN_CLK.t15 109.174
R703 E_REGEN_CLK.n16 E_REGEN_CLK.t16 109.174
R704 E_REGEN_CLK.t17 E_REGEN_CLK.n17 109.174
R705 E_REGEN_CLK.t18 E_REGEN_CLK.n3 109.174
R706 E_REGEN_CLK.n80 E_REGEN_CLK.t28 109.174
R707 E_REGEN_CLK.n79 E_REGEN_CLK.t29 109.174
R708 E_REGEN_CLK.t30 E_REGEN_CLK.n63 109.174
R709 E_REGEN_CLK.t31 E_REGEN_CLK.n75 109.174
R710 E_REGEN_CLK.n65 E_REGEN_CLK.t32 109.174
R711 E_REGEN_CLK.n71 E_REGEN_CLK.t33 109.174
R712 E_REGEN_CLK.t34 E_REGEN_CLK.n68 109.174
R713 E_REGEN_CLK.n60 E_REGEN_CLK.n0 27.7007
R714 E_REGEN_CLK.n85 E_REGEN_CLK.n84 22.692
R715 E_REGEN_CLK.n59 E_REGEN_CLK.n58 20.0962
R716 E_REGEN_CLK.n55 E_REGEN_CLK.n46 18.4942
R717 E_REGEN_CLK.n57 E_REGEN_CLK.n56 18.4942
R718 E_REGEN_CLK.n50 E_REGEN_CLK.n47 18.4942
R719 E_REGEN_CLK.n54 E_REGEN_CLK.n53 18.4942
R720 E_REGEN_CLK.n22 E_REGEN_CLK.n21 18.4942
R721 E_REGEN_CLK.n37 E_REGEN_CLK.n36 18.4942
R722 E_REGEN_CLK.n38 E_REGEN_CLK.n26 18.4942
R723 E_REGEN_CLK.n39 E_REGEN_CLK.n25 18.4942
R724 E_REGEN_CLK.n40 E_REGEN_CLK.n24 18.4942
R725 E_REGEN_CLK.n41 E_REGEN_CLK.n23 18.4942
R726 E_REGEN_CLK.n43 E_REGEN_CLK.n42 18.4942
R727 E_REGEN_CLK.n14 E_REGEN_CLK.n8 18.4942
R728 E_REGEN_CLK.n15 E_REGEN_CLK.n7 18.4942
R729 E_REGEN_CLK.n16 E_REGEN_CLK.n6 18.4942
R730 E_REGEN_CLK.n17 E_REGEN_CLK.n5 18.4942
R731 E_REGEN_CLK.n3 E_REGEN_CLK.n2 18.4942
R732 E_REGEN_CLK.n81 E_REGEN_CLK.n80 18.4942
R733 E_REGEN_CLK.n79 E_REGEN_CLK.n62 18.4942
R734 E_REGEN_CLK.n66 E_REGEN_CLK.n63 18.4942
R735 E_REGEN_CLK.n75 E_REGEN_CLK.n74 18.4942
R736 E_REGEN_CLK.n73 E_REGEN_CLK.n65 18.4942
R737 E_REGEN_CLK.n72 E_REGEN_CLK.n71 18.4942
R738 E_REGEN_CLK E_REGEN_CLK.n85 15.9857
R739 E_REGEN_CLK.n55 E_REGEN_CLK.n54 11.6805
R740 E_REGEN_CLK.n56 E_REGEN_CLK.n55 11.6805
R741 E_REGEN_CLK.n50 E_REGEN_CLK.n49 11.6805
R742 E_REGEN_CLK.n56 E_REGEN_CLK.n50 11.6805
R743 E_REGEN_CLK.n54 E_REGEN_CLK.n51 11.6805
R744 E_REGEN_CLK.n38 E_REGEN_CLK.n37 11.6805
R745 E_REGEN_CLK.n37 E_REGEN_CLK.n27 11.6805
R746 E_REGEN_CLK.n39 E_REGEN_CLK.n38 11.6805
R747 E_REGEN_CLK.n40 E_REGEN_CLK.n39 11.6805
R748 E_REGEN_CLK.n41 E_REGEN_CLK.n40 11.6805
R749 E_REGEN_CLK.n42 E_REGEN_CLK.n41 11.6805
R750 E_REGEN_CLK.n14 E_REGEN_CLK.n13 11.6805
R751 E_REGEN_CLK.n15 E_REGEN_CLK.n14 11.6805
R752 E_REGEN_CLK.n16 E_REGEN_CLK.n15 11.6805
R753 E_REGEN_CLK.n17 E_REGEN_CLK.n16 11.6805
R754 E_REGEN_CLK.n17 E_REGEN_CLK.n3 11.6805
R755 E_REGEN_CLK.n21 E_REGEN_CLK.n3 11.6805
R756 E_REGEN_CLK.n80 E_REGEN_CLK.n79 11.6805
R757 E_REGEN_CLK.n79 E_REGEN_CLK.n63 11.6805
R758 E_REGEN_CLK.n75 E_REGEN_CLK.n63 11.6805
R759 E_REGEN_CLK.n75 E_REGEN_CLK.n65 11.6805
R760 E_REGEN_CLK.n71 E_REGEN_CLK.n65 11.6805
R761 E_REGEN_CLK.n71 E_REGEN_CLK.n68 11.6805
R762 E_REGEN_CLK.n82 E_REGEN_CLK.n61 10.8876
R763 E_REGEN_CLK.n45 E_REGEN_CLK.n1 10.8396
R764 E_REGEN_CLK.n83 E_REGEN_CLK.n82 10.3248
R765 E_REGEN_CLK.n82 E_REGEN_CLK.n81 9.0485
R766 E_REGEN_CLK.n45 E_REGEN_CLK.n44 9.0005
R767 E_REGEN_CLK.n53 E_REGEN_CLK.n52 7.17687
R768 E_REGEN_CLK.n48 E_REGEN_CLK.n47 7.17687
R769 E_REGEN_CLK.n36 E_REGEN_CLK.n35 7.17687
R770 E_REGEN_CLK.n12 E_REGEN_CLK.n8 7.17687
R771 E_REGEN_CLK.n72 E_REGEN_CLK.n67 7.17687
R772 E_REGEN_CLK.n59 E_REGEN_CLK.n45 5.82479
R773 E_REGEN_CLK.n60 E_REGEN_CLK.n59 4.5005
R774 E_REGEN_CLK.n49 E_REGEN_CLK.n48 4.42851
R775 E_REGEN_CLK.n52 E_REGEN_CLK.n51 4.42851
R776 E_REGEN_CLK.n35 E_REGEN_CLK.n27 4.42851
R777 E_REGEN_CLK.n13 E_REGEN_CLK.n12 4.42851
R778 E_REGEN_CLK.n68 E_REGEN_CLK.n67 4.42851
R779 E_REGEN_CLK.n85 E_REGEN_CLK.n83 3.83528
R780 E_REGEN_CLK.n83 E_REGEN_CLK.n60 2.89615
R781 E_REGEN_CLK.n44 E_REGEN_CLK.n22 0.4685
R782 E_REGEN_CLK.n20 E_REGEN_CLK.n1 0.4685
R783 E_REGEN_CLK.n28 E_REGEN_CLK.n1 0.4685
R784 E_REGEN_CLK.n44 E_REGEN_CLK.n43 0.4685
R785 E_REGEN_CLK.n53 E_REGEN_CLK.n46 0.1205
R786 E_REGEN_CLK.n57 E_REGEN_CLK.n47 0.1205
R787 E_REGEN_CLK.n22 E_REGEN_CLK.n2 0.1205
R788 E_REGEN_CLK.n5 E_REGEN_CLK.n2 0.1205
R789 E_REGEN_CLK.n6 E_REGEN_CLK.n5 0.1205
R790 E_REGEN_CLK.n7 E_REGEN_CLK.n6 0.1205
R791 E_REGEN_CLK.n8 E_REGEN_CLK.n7 0.1205
R792 E_REGEN_CLK.n20 E_REGEN_CLK.n19 0.1205
R793 E_REGEN_CLK.n19 E_REGEN_CLK.n18 0.1205
R794 E_REGEN_CLK.n18 E_REGEN_CLK.n4 0.1205
R795 E_REGEN_CLK.n9 E_REGEN_CLK.n4 0.1205
R796 E_REGEN_CLK.n10 E_REGEN_CLK.n9 0.1205
R797 E_REGEN_CLK.n11 E_REGEN_CLK.n10 0.1205
R798 E_REGEN_CLK.n34 E_REGEN_CLK.n33 0.1205
R799 E_REGEN_CLK.n33 E_REGEN_CLK.n32 0.1205
R800 E_REGEN_CLK.n32 E_REGEN_CLK.n31 0.1205
R801 E_REGEN_CLK.n31 E_REGEN_CLK.n30 0.1205
R802 E_REGEN_CLK.n30 E_REGEN_CLK.n29 0.1205
R803 E_REGEN_CLK.n29 E_REGEN_CLK.n28 0.1205
R804 E_REGEN_CLK.n36 E_REGEN_CLK.n26 0.1205
R805 E_REGEN_CLK.n26 E_REGEN_CLK.n25 0.1205
R806 E_REGEN_CLK.n25 E_REGEN_CLK.n24 0.1205
R807 E_REGEN_CLK.n24 E_REGEN_CLK.n23 0.1205
R808 E_REGEN_CLK.n43 E_REGEN_CLK.n23 0.1205
R809 E_REGEN_CLK.n73 E_REGEN_CLK.n72 0.1205
R810 E_REGEN_CLK.n74 E_REGEN_CLK.n73 0.1205
R811 E_REGEN_CLK.n74 E_REGEN_CLK.n66 0.1205
R812 E_REGEN_CLK.n66 E_REGEN_CLK.n62 0.1205
R813 E_REGEN_CLK.n81 E_REGEN_CLK.n62 0.1205
R814 E_REGEN_CLK.n70 E_REGEN_CLK.n69 0.1205
R815 E_REGEN_CLK.n70 E_REGEN_CLK.n64 0.1205
R816 E_REGEN_CLK.n76 E_REGEN_CLK.n64 0.1205
R817 E_REGEN_CLK.n77 E_REGEN_CLK.n76 0.1205
R818 E_REGEN_CLK.n78 E_REGEN_CLK.n77 0.1205
R819 E_REGEN_CLK.n78 E_REGEN_CLK.n61 0.1205
R820 E_REGEN_CLK.n58 E_REGEN_CLK.n46 0.0485
R821 E_REGEN_CLK.n58 E_REGEN_CLK.n57 0.0485
R822 O_REGEN_CLKB.t7 O_REGEN_CLKB.n32 127.788
R823 O_REGEN_CLKB.n16 O_REGEN_CLKB.t15 127.788
R824 O_REGEN_CLKB.t8 O_REGEN_CLKB.n7 127.788
R825 O_REGEN_CLKB.t0 O_REGEN_CLKB.n21 127.737
R826 O_REGEN_CLKB.n32 O_REGEN_CLKB.t6 127.668
R827 O_REGEN_CLKB.n31 O_REGEN_CLKB.t5 127.668
R828 O_REGEN_CLKB.n30 O_REGEN_CLKB.t4 127.668
R829 O_REGEN_CLKB.n29 O_REGEN_CLKB.t3 127.668
R830 O_REGEN_CLKB.n28 O_REGEN_CLKB.t2 127.668
R831 O_REGEN_CLKB.n27 O_REGEN_CLKB.t1 127.668
R832 O_REGEN_CLKB.t13 O_REGEN_CLKB.n14 127.668
R833 O_REGEN_CLKB.t14 O_REGEN_CLKB.n16 127.668
R834 O_REGEN_CLKB.n7 O_REGEN_CLKB.t9 127.668
R835 O_REGEN_CLKB.t10 O_REGEN_CLKB.n3 127.668
R836 O_REGEN_CLKB.n12 O_REGEN_CLKB.t11 127.668
R837 O_REGEN_CLKB.n13 O_REGEN_CLKB.t12 127.668
R838 O_REGEN_CLKB.n33 O_REGEN_CLKB.t7 113.632
R839 O_REGEN_CLKB.n18 O_REGEN_CLKB.t15 113.632
R840 O_REGEN_CLKB.n8 O_REGEN_CLKB.t8 113.632
R841 O_REGEN_CLKB.n22 O_REGEN_CLKB.t0 109.174
R842 O_REGEN_CLKB.t6 O_REGEN_CLKB.n26 109.174
R843 O_REGEN_CLKB.n35 O_REGEN_CLKB.t5 109.174
R844 O_REGEN_CLKB.n36 O_REGEN_CLKB.t4 109.174
R845 O_REGEN_CLKB.n37 O_REGEN_CLKB.t3 109.174
R846 O_REGEN_CLKB.n38 O_REGEN_CLKB.t2 109.174
R847 O_REGEN_CLKB.n39 O_REGEN_CLKB.t1 109.174
R848 O_REGEN_CLKB.n15 O_REGEN_CLKB.t13 109.174
R849 O_REGEN_CLKB.n17 O_REGEN_CLKB.t14 109.174
R850 O_REGEN_CLKB.n9 O_REGEN_CLKB.t9 109.174
R851 O_REGEN_CLKB.n10 O_REGEN_CLKB.t10 109.174
R852 O_REGEN_CLKB.t11 O_REGEN_CLKB.n11 109.174
R853 O_REGEN_CLKB.t12 O_REGEN_CLKB.n2 109.174
R854 O_REGEN_CLKB.n43 O_REGEN_CLKB.n20 24.2273
R855 O_REGEN_CLKB.n41 O_REGEN_CLKB.n22 18.5636
R856 O_REGEN_CLKB.n35 O_REGEN_CLKB.n34 18.4942
R857 O_REGEN_CLKB.n36 O_REGEN_CLKB.n25 18.4942
R858 O_REGEN_CLKB.n37 O_REGEN_CLKB.n24 18.4942
R859 O_REGEN_CLKB.n38 O_REGEN_CLKB.n23 18.4942
R860 O_REGEN_CLKB.n40 O_REGEN_CLKB.n39 18.4942
R861 O_REGEN_CLKB.n15 O_REGEN_CLKB.n1 18.4942
R862 O_REGEN_CLKB.n10 O_REGEN_CLKB.n6 18.4942
R863 O_REGEN_CLKB.n11 O_REGEN_CLKB.n5 18.4942
R864 O_REGEN_CLKB.n4 O_REGEN_CLKB.n2 18.4942
R865 O_REGEN_CLKB O_REGEN_CLKB.n43 16.7683
R866 O_REGEN_CLKB.n43 O_REGEN_CLKB.n42 14.0534
R867 O_REGEN_CLKB.n36 O_REGEN_CLKB.n35 11.6805
R868 O_REGEN_CLKB.n35 O_REGEN_CLKB.n26 11.6805
R869 O_REGEN_CLKB.n37 O_REGEN_CLKB.n36 11.6805
R870 O_REGEN_CLKB.n38 O_REGEN_CLKB.n37 11.6805
R871 O_REGEN_CLKB.n39 O_REGEN_CLKB.n38 11.6805
R872 O_REGEN_CLKB.n39 O_REGEN_CLKB.n22 11.6805
R873 O_REGEN_CLKB.n17 O_REGEN_CLKB.n15 11.6805
R874 O_REGEN_CLKB.n10 O_REGEN_CLKB.n9 11.6805
R875 O_REGEN_CLKB.n11 O_REGEN_CLKB.n10 11.6805
R876 O_REGEN_CLKB.n11 O_REGEN_CLKB.n2 11.6805
R877 O_REGEN_CLKB.n15 O_REGEN_CLKB.n2 11.6805
R878 O_REGEN_CLKB.n42 O_REGEN_CLKB.n21 10.8396
R879 O_REGEN_CLKB.n20 O_REGEN_CLKB.n0 10.8396
R880 O_REGEN_CLKB.n42 O_REGEN_CLKB.n41 9.0005
R881 O_REGEN_CLKB.n20 O_REGEN_CLKB.n19 9.0005
R882 O_REGEN_CLKB.n34 O_REGEN_CLKB.n33 7.17687
R883 O_REGEN_CLKB.n8 O_REGEN_CLKB.n6 7.17687
R884 O_REGEN_CLKB.n19 O_REGEN_CLKB.n18 7.10487
R885 O_REGEN_CLKB.n33 O_REGEN_CLKB.n26 4.42851
R886 O_REGEN_CLKB.n18 O_REGEN_CLKB.n17 4.42851
R887 O_REGEN_CLKB.n9 O_REGEN_CLKB.n8 4.42851
R888 O_REGEN_CLKB.n32 O_REGEN_CLKB.n31 0.1205
R889 O_REGEN_CLKB.n31 O_REGEN_CLKB.n30 0.1205
R890 O_REGEN_CLKB.n30 O_REGEN_CLKB.n29 0.1205
R891 O_REGEN_CLKB.n29 O_REGEN_CLKB.n28 0.1205
R892 O_REGEN_CLKB.n28 O_REGEN_CLKB.n27 0.1205
R893 O_REGEN_CLKB.n34 O_REGEN_CLKB.n25 0.1205
R894 O_REGEN_CLKB.n25 O_REGEN_CLKB.n24 0.1205
R895 O_REGEN_CLKB.n24 O_REGEN_CLKB.n23 0.1205
R896 O_REGEN_CLKB.n40 O_REGEN_CLKB.n23 0.1205
R897 O_REGEN_CLKB.n4 O_REGEN_CLKB.n1 0.1205
R898 O_REGEN_CLKB.n5 O_REGEN_CLKB.n4 0.1205
R899 O_REGEN_CLKB.n6 O_REGEN_CLKB.n5 0.1205
R900 O_REGEN_CLKB.n14 O_REGEN_CLKB.n13 0.1205
R901 O_REGEN_CLKB.n13 O_REGEN_CLKB.n12 0.1205
R902 O_REGEN_CLKB.n12 O_REGEN_CLKB.n3 0.1205
R903 O_REGEN_CLKB.n7 O_REGEN_CLKB.n3 0.1205
R904 O_REGEN_CLKB.n27 O_REGEN_CLKB.n21 0.0485
R905 O_REGEN_CLKB.n41 O_REGEN_CLKB.n40 0.0485
R906 O_REGEN_CLKB.n19 O_REGEN_CLKB.n1 0.0485
R907 O_REGEN_CLKB.n14 O_REGEN_CLKB.n0 0.0485
R908 O_REGEN_CLKB.n16 O_REGEN_CLKB.n0 0.0485
R909 E_REGEN_CLKB.t7 E_REGEN_CLKB.n11 127.788
R910 E_REGEN_CLKB.n3 E_REGEN_CLKB.t0 127.788
R911 E_REGEN_CLKB.t8 E_REGEN_CLKB.n30 127.788
R912 E_REGEN_CLKB.t15 E_REGEN_CLKB.n21 127.737
R913 E_REGEN_CLKB.t1 E_REGEN_CLKB.n3 127.668
R914 E_REGEN_CLKB.n11 E_REGEN_CLKB.t6 127.668
R915 E_REGEN_CLKB.n10 E_REGEN_CLKB.t5 127.668
R916 E_REGEN_CLKB.n9 E_REGEN_CLKB.t4 127.668
R917 E_REGEN_CLKB.n8 E_REGEN_CLKB.t3 127.668
R918 E_REGEN_CLKB.n7 E_REGEN_CLKB.t2 127.668
R919 E_REGEN_CLKB.t14 E_REGEN_CLKB.n38 127.668
R920 E_REGEN_CLKB.n30 E_REGEN_CLKB.t9 127.668
R921 E_REGEN_CLKB.n29 E_REGEN_CLKB.t10 127.668
R922 E_REGEN_CLKB.t11 E_REGEN_CLKB.n24 127.668
R923 E_REGEN_CLKB.n36 E_REGEN_CLKB.t12 127.668
R924 E_REGEN_CLKB.n37 E_REGEN_CLKB.t13 127.668
R925 E_REGEN_CLKB.n12 E_REGEN_CLKB.t7 113.632
R926 E_REGEN_CLKB.t0 E_REGEN_CLKB.n1 113.632
R927 E_REGEN_CLKB.n31 E_REGEN_CLKB.t8 113.632
R928 E_REGEN_CLKB.n4 E_REGEN_CLKB.t1 109.174
R929 E_REGEN_CLKB.t6 E_REGEN_CLKB.n6 109.174
R930 E_REGEN_CLKB.n14 E_REGEN_CLKB.t5 109.174
R931 E_REGEN_CLKB.n15 E_REGEN_CLKB.t4 109.174
R932 E_REGEN_CLKB.n16 E_REGEN_CLKB.t3 109.174
R933 E_REGEN_CLKB.n17 E_REGEN_CLKB.t2 109.174
R934 E_REGEN_CLKB.n39 E_REGEN_CLKB.t14 109.174
R935 E_REGEN_CLKB.n40 E_REGEN_CLKB.t15 109.174
R936 E_REGEN_CLKB.n32 E_REGEN_CLKB.t9 109.174
R937 E_REGEN_CLKB.n33 E_REGEN_CLKB.t10 109.174
R938 E_REGEN_CLKB.n34 E_REGEN_CLKB.t11 109.174
R939 E_REGEN_CLKB.t12 E_REGEN_CLKB.n35 109.174
R940 E_REGEN_CLKB.t13 E_REGEN_CLKB.n23 109.174
R941 E_REGEN_CLKB.n43 E_REGEN_CLKB.n20 24.2273
R942 E_REGEN_CLKB.n41 E_REGEN_CLKB.n40 18.5636
R943 E_REGEN_CLKB.n14 E_REGEN_CLKB.n13 18.4942
R944 E_REGEN_CLKB.n15 E_REGEN_CLKB.n5 18.4942
R945 E_REGEN_CLKB.n16 E_REGEN_CLKB.n2 18.4942
R946 E_REGEN_CLKB.n18 E_REGEN_CLKB.n17 18.4942
R947 E_REGEN_CLKB.n39 E_REGEN_CLKB.n22 18.4942
R948 E_REGEN_CLKB.n33 E_REGEN_CLKB.n28 18.4942
R949 E_REGEN_CLKB.n34 E_REGEN_CLKB.n27 18.4942
R950 E_REGEN_CLKB.n35 E_REGEN_CLKB.n26 18.4942
R951 E_REGEN_CLKB.n25 E_REGEN_CLKB.n23 18.4942
R952 E_REGEN_CLKB E_REGEN_CLKB.n43 16.7683
R953 E_REGEN_CLKB.n43 E_REGEN_CLKB.n42 14.0534
R954 E_REGEN_CLKB.n15 E_REGEN_CLKB.n14 11.6805
R955 E_REGEN_CLKB.n14 E_REGEN_CLKB.n6 11.6805
R956 E_REGEN_CLKB.n16 E_REGEN_CLKB.n15 11.6805
R957 E_REGEN_CLKB.n17 E_REGEN_CLKB.n16 11.6805
R958 E_REGEN_CLKB.n17 E_REGEN_CLKB.n4 11.6805
R959 E_REGEN_CLKB.n40 E_REGEN_CLKB.n39 11.6805
R960 E_REGEN_CLKB.n33 E_REGEN_CLKB.n32 11.6805
R961 E_REGEN_CLKB.n34 E_REGEN_CLKB.n33 11.6805
R962 E_REGEN_CLKB.n35 E_REGEN_CLKB.n34 11.6805
R963 E_REGEN_CLKB.n35 E_REGEN_CLKB.n23 11.6805
R964 E_REGEN_CLKB.n39 E_REGEN_CLKB.n23 11.6805
R965 E_REGEN_CLKB.n20 E_REGEN_CLKB.n0 10.8396
R966 E_REGEN_CLKB.n42 E_REGEN_CLKB.n21 10.8396
R967 E_REGEN_CLKB.n20 E_REGEN_CLKB.n19 9.0005
R968 E_REGEN_CLKB.n42 E_REGEN_CLKB.n41 9.0005
R969 E_REGEN_CLKB.n13 E_REGEN_CLKB.n12 7.17687
R970 E_REGEN_CLKB.n31 E_REGEN_CLKB.n28 7.17687
R971 E_REGEN_CLKB.n19 E_REGEN_CLKB.n1 7.10487
R972 E_REGEN_CLKB.n4 E_REGEN_CLKB.n1 4.42851
R973 E_REGEN_CLKB.n12 E_REGEN_CLKB.n6 4.42851
R974 E_REGEN_CLKB.n32 E_REGEN_CLKB.n31 4.42851
R975 E_REGEN_CLKB.n11 E_REGEN_CLKB.n10 0.1205
R976 E_REGEN_CLKB.n10 E_REGEN_CLKB.n9 0.1205
R977 E_REGEN_CLKB.n9 E_REGEN_CLKB.n8 0.1205
R978 E_REGEN_CLKB.n8 E_REGEN_CLKB.n7 0.1205
R979 E_REGEN_CLKB.n13 E_REGEN_CLKB.n5 0.1205
R980 E_REGEN_CLKB.n5 E_REGEN_CLKB.n2 0.1205
R981 E_REGEN_CLKB.n18 E_REGEN_CLKB.n2 0.1205
R982 E_REGEN_CLKB.n25 E_REGEN_CLKB.n22 0.1205
R983 E_REGEN_CLKB.n26 E_REGEN_CLKB.n25 0.1205
R984 E_REGEN_CLKB.n27 E_REGEN_CLKB.n26 0.1205
R985 E_REGEN_CLKB.n28 E_REGEN_CLKB.n27 0.1205
R986 E_REGEN_CLKB.n38 E_REGEN_CLKB.n37 0.1205
R987 E_REGEN_CLKB.n37 E_REGEN_CLKB.n36 0.1205
R988 E_REGEN_CLKB.n36 E_REGEN_CLKB.n24 0.1205
R989 E_REGEN_CLKB.n29 E_REGEN_CLKB.n24 0.1205
R990 E_REGEN_CLKB.n30 E_REGEN_CLKB.n29 0.1205
R991 E_REGEN_CLKB.n3 E_REGEN_CLKB.n0 0.0485
R992 E_REGEN_CLKB.n7 E_REGEN_CLKB.n0 0.0485
R993 E_REGEN_CLKB.n19 E_REGEN_CLKB.n18 0.0485
R994 E_REGEN_CLKB.n41 E_REGEN_CLKB.n22 0.0485
R995 E_REGEN_CLKB.n38 E_REGEN_CLKB.n21 0.0485
R996 O_CAPTURE_CLK.n14 O_CAPTURE_CLK.t8 113.632
R997 O_CAPTURE_CLK.n18 O_CAPTURE_CLK.t15 113.632
R998 O_CAPTURE_CLK.n5 O_CAPTURE_CLK.t7 113.632
R999 O_CAPTURE_CLK.n23 O_CAPTURE_CLK.t9 109.174
R1000 O_CAPTURE_CLK.n24 O_CAPTURE_CLK.t10 109.174
R1001 O_CAPTURE_CLK.n22 O_CAPTURE_CLK.t11 109.174
R1002 O_CAPTURE_CLK.n21 O_CAPTURE_CLK.t12 109.174
R1003 O_CAPTURE_CLK.n16 O_CAPTURE_CLK.t13 109.174
R1004 O_CAPTURE_CLK.n17 O_CAPTURE_CLK.t14 109.174
R1005 O_CAPTURE_CLK.n0 O_CAPTURE_CLK.t0 109.174
R1006 O_CAPTURE_CLK.n11 O_CAPTURE_CLK.t1 109.174
R1007 O_CAPTURE_CLK.n6 O_CAPTURE_CLK.t6 109.174
R1008 O_CAPTURE_CLK.n7 O_CAPTURE_CLK.t5 109.174
R1009 O_CAPTURE_CLK.n8 O_CAPTURE_CLK.t4 109.174
R1010 O_CAPTURE_CLK.n9 O_CAPTURE_CLK.t3 109.174
R1011 O_CAPTURE_CLK.n10 O_CAPTURE_CLK.t2 109.174
R1012 O_CAPTURE_CLK.n27 O_CAPTURE_CLK.n13 19.4679
R1013 O_CAPTURE_CLK O_CAPTURE_CLK.n27 18.7296
R1014 O_CAPTURE_CLK.n13 O_CAPTURE_CLK.n0 18.5636
R1015 O_CAPTURE_CLK.n25 O_CAPTURE_CLK.n24 18.4942
R1016 O_CAPTURE_CLK.n22 O_CAPTURE_CLK.n15 18.4942
R1017 O_CAPTURE_CLK.n21 O_CAPTURE_CLK.n20 18.4942
R1018 O_CAPTURE_CLK.n19 O_CAPTURE_CLK.n16 18.4942
R1019 O_CAPTURE_CLK.n12 O_CAPTURE_CLK.n11 18.4942
R1020 O_CAPTURE_CLK.n7 O_CAPTURE_CLK.n4 18.4942
R1021 O_CAPTURE_CLK.n8 O_CAPTURE_CLK.n3 18.4942
R1022 O_CAPTURE_CLK.n9 O_CAPTURE_CLK.n2 18.4942
R1023 O_CAPTURE_CLK.n10 O_CAPTURE_CLK.n1 18.4942
R1024 O_CAPTURE_CLK.n27 O_CAPTURE_CLK.n26 14.9288
R1025 O_CAPTURE_CLK.n24 O_CAPTURE_CLK.n23 11.6805
R1026 O_CAPTURE_CLK.n24 O_CAPTURE_CLK.n22 11.6805
R1027 O_CAPTURE_CLK.n22 O_CAPTURE_CLK.n21 11.6805
R1028 O_CAPTURE_CLK.n21 O_CAPTURE_CLK.n16 11.6805
R1029 O_CAPTURE_CLK.n17 O_CAPTURE_CLK.n16 11.6805
R1030 O_CAPTURE_CLK.n11 O_CAPTURE_CLK.n0 11.6805
R1031 O_CAPTURE_CLK.n7 O_CAPTURE_CLK.n6 11.6805
R1032 O_CAPTURE_CLK.n8 O_CAPTURE_CLK.n7 11.6805
R1033 O_CAPTURE_CLK.n9 O_CAPTURE_CLK.n8 11.6805
R1034 O_CAPTURE_CLK.n10 O_CAPTURE_CLK.n9 11.6805
R1035 O_CAPTURE_CLK.n11 O_CAPTURE_CLK.n10 11.6805
R1036 O_CAPTURE_CLK.n19 O_CAPTURE_CLK.n18 7.17687
R1037 O_CAPTURE_CLK.n5 O_CAPTURE_CLK.n4 7.17687
R1038 O_CAPTURE_CLK.n26 O_CAPTURE_CLK.n14 7.10487
R1039 O_CAPTURE_CLK.n23 O_CAPTURE_CLK.n14 4.42851
R1040 O_CAPTURE_CLK.n18 O_CAPTURE_CLK.n17 4.42851
R1041 O_CAPTURE_CLK.n6 O_CAPTURE_CLK.n5 4.42851
R1042 O_CAPTURE_CLK.n20 O_CAPTURE_CLK.n19 0.1205
R1043 O_CAPTURE_CLK.n20 O_CAPTURE_CLK.n15 0.1205
R1044 O_CAPTURE_CLK.n25 O_CAPTURE_CLK.n15 0.1205
R1045 O_CAPTURE_CLK.n4 O_CAPTURE_CLK.n3 0.1205
R1046 O_CAPTURE_CLK.n3 O_CAPTURE_CLK.n2 0.1205
R1047 O_CAPTURE_CLK.n2 O_CAPTURE_CLK.n1 0.1205
R1048 O_CAPTURE_CLK.n12 O_CAPTURE_CLK.n1 0.1205
R1049 O_CAPTURE_CLK.n26 O_CAPTURE_CLK.n25 0.0485
R1050 O_CAPTURE_CLK.n13 O_CAPTURE_CLK.n12 0.0485
R1051 E_CAPTURE_CLK.n5 E_CAPTURE_CLK.t7 113.632
R1052 E_CAPTURE_CLK.n14 E_CAPTURE_CLK.t8 113.632
R1053 E_CAPTURE_CLK.n18 E_CAPTURE_CLK.t15 113.632
R1054 E_CAPTURE_CLK.n0 E_CAPTURE_CLK.t0 109.174
R1055 E_CAPTURE_CLK.n11 E_CAPTURE_CLK.t1 109.174
R1056 E_CAPTURE_CLK.n6 E_CAPTURE_CLK.t6 109.174
R1057 E_CAPTURE_CLK.n7 E_CAPTURE_CLK.t5 109.174
R1058 E_CAPTURE_CLK.n8 E_CAPTURE_CLK.t4 109.174
R1059 E_CAPTURE_CLK.n9 E_CAPTURE_CLK.t3 109.174
R1060 E_CAPTURE_CLK.n10 E_CAPTURE_CLK.t2 109.174
R1061 E_CAPTURE_CLK.n23 E_CAPTURE_CLK.t9 109.174
R1062 E_CAPTURE_CLK.n24 E_CAPTURE_CLK.t10 109.174
R1063 E_CAPTURE_CLK.n22 E_CAPTURE_CLK.t11 109.174
R1064 E_CAPTURE_CLK.n21 E_CAPTURE_CLK.t12 109.174
R1065 E_CAPTURE_CLK.n16 E_CAPTURE_CLK.t13 109.174
R1066 E_CAPTURE_CLK.n17 E_CAPTURE_CLK.t14 109.174
R1067 E_CAPTURE_CLK E_CAPTURE_CLK.n27 19.486
R1068 E_CAPTURE_CLK.n13 E_CAPTURE_CLK.n0 18.5636
R1069 E_CAPTURE_CLK.n12 E_CAPTURE_CLK.n11 18.4942
R1070 E_CAPTURE_CLK.n7 E_CAPTURE_CLK.n4 18.4942
R1071 E_CAPTURE_CLK.n8 E_CAPTURE_CLK.n3 18.4942
R1072 E_CAPTURE_CLK.n9 E_CAPTURE_CLK.n2 18.4942
R1073 E_CAPTURE_CLK.n10 E_CAPTURE_CLK.n1 18.4942
R1074 E_CAPTURE_CLK.n25 E_CAPTURE_CLK.n24 18.4942
R1075 E_CAPTURE_CLK.n22 E_CAPTURE_CLK.n15 18.4942
R1076 E_CAPTURE_CLK.n21 E_CAPTURE_CLK.n20 18.4942
R1077 E_CAPTURE_CLK.n19 E_CAPTURE_CLK.n16 18.4942
R1078 E_CAPTURE_CLK.n27 E_CAPTURE_CLK.n13 18.4114
R1079 E_CAPTURE_CLK.n27 E_CAPTURE_CLK.n26 13.5592
R1080 E_CAPTURE_CLK.n11 E_CAPTURE_CLK.n0 11.6805
R1081 E_CAPTURE_CLK.n7 E_CAPTURE_CLK.n6 11.6805
R1082 E_CAPTURE_CLK.n8 E_CAPTURE_CLK.n7 11.6805
R1083 E_CAPTURE_CLK.n9 E_CAPTURE_CLK.n8 11.6805
R1084 E_CAPTURE_CLK.n10 E_CAPTURE_CLK.n9 11.6805
R1085 E_CAPTURE_CLK.n11 E_CAPTURE_CLK.n10 11.6805
R1086 E_CAPTURE_CLK.n24 E_CAPTURE_CLK.n23 11.6805
R1087 E_CAPTURE_CLK.n24 E_CAPTURE_CLK.n22 11.6805
R1088 E_CAPTURE_CLK.n22 E_CAPTURE_CLK.n21 11.6805
R1089 E_CAPTURE_CLK.n21 E_CAPTURE_CLK.n16 11.6805
R1090 E_CAPTURE_CLK.n17 E_CAPTURE_CLK.n16 11.6805
R1091 E_CAPTURE_CLK.n5 E_CAPTURE_CLK.n4 7.17687
R1092 E_CAPTURE_CLK.n19 E_CAPTURE_CLK.n18 7.17687
R1093 E_CAPTURE_CLK.n26 E_CAPTURE_CLK.n14 7.10487
R1094 E_CAPTURE_CLK.n6 E_CAPTURE_CLK.n5 4.42851
R1095 E_CAPTURE_CLK.n23 E_CAPTURE_CLK.n14 4.42851
R1096 E_CAPTURE_CLK.n18 E_CAPTURE_CLK.n17 4.42851
R1097 E_CAPTURE_CLK.n4 E_CAPTURE_CLK.n3 0.1205
R1098 E_CAPTURE_CLK.n3 E_CAPTURE_CLK.n2 0.1205
R1099 E_CAPTURE_CLK.n2 E_CAPTURE_CLK.n1 0.1205
R1100 E_CAPTURE_CLK.n12 E_CAPTURE_CLK.n1 0.1205
R1101 E_CAPTURE_CLK.n20 E_CAPTURE_CLK.n19 0.1205
R1102 E_CAPTURE_CLK.n20 E_CAPTURE_CLK.n15 0.1205
R1103 E_CAPTURE_CLK.n25 E_CAPTURE_CLK.n15 0.1205
R1104 E_CAPTURE_CLK.n13 E_CAPTURE_CLK.n12 0.0485
R1105 E_CAPTURE_CLK.n26 E_CAPTURE_CLK.n25 0.0485
R1106 FE_O_N.n16 FE_O_N.t17 113.632
R1107 FE_O_N.n13 FE_O_N.t14 113.632
R1108 FE_O_N.n6 FE_O_N.t18 113.632
R1109 FE_O_N.n2 FE_O_N.t25 113.632
R1110 FE_O_N.n14 FE_O_N.t15 109.174
R1111 FE_O_N.n15 FE_O_N.t16 109.174
R1112 FE_O_N.n7 FE_O_N.t19 109.174
R1113 FE_O_N.n8 FE_O_N.t20 109.174
R1114 FE_O_N.n9 FE_O_N.t21 109.174
R1115 FE_O_N.n10 FE_O_N.t22 109.174
R1116 FE_O_N.n4 FE_O_N.t23 109.174
R1117 FE_O_N.n3 FE_O_N.t24 109.174
R1118 FE_O_N.n32 FE_O_N.n18 74.8513
R1119 FE_O_N.n8 FE_O_N.n5 18.4942
R1120 FE_O_N.n9 FE_O_N.n0 18.4942
R1121 FE_O_N.n11 FE_O_N.n10 18.4942
R1122 FE_O_N.n4 FE_O_N.n1 18.4942
R1123 FE_O_N.n18 FE_O_N.n12 14.8701
R1124 FE_O_N.n15 FE_O_N.n14 11.6805
R1125 FE_O_N.n8 FE_O_N.n7 11.6805
R1126 FE_O_N.n9 FE_O_N.n8 11.6805
R1127 FE_O_N.n10 FE_O_N.n9 11.6805
R1128 FE_O_N.n10 FE_O_N.n4 11.6805
R1129 FE_O_N.n4 FE_O_N.n3 11.6805
R1130 FE_O_N.n32 FE_O_N.n31 11.3092
R1131 FE_O_N.n31 FE_O_N.n30 9.42986
R1132 FE_O_N.n18 FE_O_N.n17 9.0005
R1133 FE_O_N.n6 FE_O_N.n5 7.17687
R1134 FE_O_N.n2 FE_O_N.n1 7.17687
R1135 FE_O_N.n17 FE_O_N.n13 7.10487
R1136 FE_O_N.n17 FE_O_N.n16 7.10487
R1137 FE_O_N.n31 FE_O_N.n25 7.01407
R1138 FE_O_N.n27 FE_O_N.t11 5.7796
R1139 FE_O_N.n20 FE_O_N.t6 5.73764
R1140 FE_O_N.n24 FE_O_N.t2 5.73764
R1141 FE_O_N.n30 FE_O_N.t5 5.59012
R1142 FE_O_N.n27 FE_O_N.n26 5.38537
R1143 FE_O_N.n29 FE_O_N.n28 5.38537
R1144 FE_O_N.n20 FE_O_N.n19 5.32067
R1145 FE_O_N.n22 FE_O_N.n21 5.32067
R1146 FE_O_N.n24 FE_O_N.n23 5.32067
R1147 FE_O_N.n14 FE_O_N.n13 4.42851
R1148 FE_O_N.n16 FE_O_N.n15 4.42851
R1149 FE_O_N.n7 FE_O_N.n6 4.42851
R1150 FE_O_N.n3 FE_O_N.n2 4.42851
R1151 FE_O_N.n19 FE_O_N.t8 0.228
R1152 FE_O_N.n19 FE_O_N.t7 0.228
R1153 FE_O_N.n21 FE_O_N.t10 0.228
R1154 FE_O_N.n21 FE_O_N.t9 0.228
R1155 FE_O_N.n23 FE_O_N.t1 0.228
R1156 FE_O_N.n23 FE_O_N.t0 0.228
R1157 FE_O_N.n26 FE_O_N.t13 0.20525
R1158 FE_O_N.n26 FE_O_N.t12 0.20525
R1159 FE_O_N.n28 FE_O_N.t4 0.20525
R1160 FE_O_N.n28 FE_O_N.t3 0.20525
R1161 FE_O_N.n30 FE_O_N.n29 0.189974
R1162 FE_O_N.n29 FE_O_N.n27 0.189974
R1163 FE_O_N.n22 FE_O_N.n20 0.189974
R1164 FE_O_N.n5 FE_O_N.n0 0.1205
R1165 FE_O_N.n11 FE_O_N.n1 0.1205
R1166 FE_O_N.n25 FE_O_N.n24 0.0952368
R1167 FE_O_N.n25 FE_O_N.n22 0.0952368
R1168 FE_O_N.n12 FE_O_N.n0 0.0485
R1169 FE_O_N.n12 FE_O_N.n11 0.0485
R1170 FE_O_N FE_O_N.n32 0.0205
R1171 FE_O_P.n16 FE_O_P.t17 113.632
R1172 FE_O_P.n13 FE_O_P.t14 113.632
R1173 FE_O_P.n6 FE_O_P.t18 113.632
R1174 FE_O_P.n2 FE_O_P.t25 113.632
R1175 FE_O_P.n14 FE_O_P.t15 109.174
R1176 FE_O_P.n15 FE_O_P.t16 109.174
R1177 FE_O_P.n7 FE_O_P.t19 109.174
R1178 FE_O_P.n8 FE_O_P.t20 109.174
R1179 FE_O_P.n9 FE_O_P.t21 109.174
R1180 FE_O_P.n10 FE_O_P.t22 109.174
R1181 FE_O_P.n4 FE_O_P.t23 109.174
R1182 FE_O_P.n3 FE_O_P.t24 109.174
R1183 FE_O_P FE_O_P.n18 76.9565
R1184 FE_O_P.n8 FE_O_P.n5 18.4942
R1185 FE_O_P.n9 FE_O_P.n0 18.4942
R1186 FE_O_P.n11 FE_O_P.n10 18.4942
R1187 FE_O_P.n4 FE_O_P.n1 18.4942
R1188 FE_O_P.n18 FE_O_P.n12 14.8701
R1189 FE_O_P.n15 FE_O_P.n14 11.6805
R1190 FE_O_P.n8 FE_O_P.n7 11.6805
R1191 FE_O_P.n9 FE_O_P.n8 11.6805
R1192 FE_O_P.n10 FE_O_P.n9 11.6805
R1193 FE_O_P.n10 FE_O_P.n4 11.6805
R1194 FE_O_P.n4 FE_O_P.n3 11.6805
R1195 FE_O_P FE_O_P.n31 11.0162
R1196 FE_O_P.n18 FE_O_P.n17 9.0005
R1197 FE_O_P.n31 FE_O_P.n30 8.81407
R1198 FE_O_P.n31 FE_O_P.n25 7.46407
R1199 FE_O_P.n6 FE_O_P.n5 7.17687
R1200 FE_O_P.n2 FE_O_P.n1 7.17687
R1201 FE_O_P.n17 FE_O_P.n13 7.10487
R1202 FE_O_P.n17 FE_O_P.n16 7.10487
R1203 FE_O_P.n27 FE_O_P.t5 5.7796
R1204 FE_O_P.n20 FE_O_P.t6 5.73764
R1205 FE_O_P.n24 FE_O_P.t0 5.73764
R1206 FE_O_P.n30 FE_O_P.t13 5.61381
R1207 FE_O_P.n29 FE_O_P.n28 5.38537
R1208 FE_O_P.n27 FE_O_P.n26 5.38537
R1209 FE_O_P.n20 FE_O_P.n19 5.32067
R1210 FE_O_P.n22 FE_O_P.n21 5.32067
R1211 FE_O_P.n24 FE_O_P.n23 5.32067
R1212 FE_O_P.n14 FE_O_P.n13 4.42851
R1213 FE_O_P.n16 FE_O_P.n15 4.42851
R1214 FE_O_P.n7 FE_O_P.n6 4.42851
R1215 FE_O_P.n3 FE_O_P.n2 4.42851
R1216 FE_O_P.n19 FE_O_P.t8 0.228
R1217 FE_O_P.n19 FE_O_P.t7 0.228
R1218 FE_O_P.n21 FE_O_P.t2 0.228
R1219 FE_O_P.n21 FE_O_P.t1 0.228
R1220 FE_O_P.n23 FE_O_P.t4 0.228
R1221 FE_O_P.n23 FE_O_P.t3 0.228
R1222 FE_O_P.n28 FE_O_P.t10 0.20525
R1223 FE_O_P.n28 FE_O_P.t9 0.20525
R1224 FE_O_P.n26 FE_O_P.t12 0.20525
R1225 FE_O_P.n26 FE_O_P.t11 0.20525
R1226 FE_O_P.n29 FE_O_P.n27 0.189974
R1227 FE_O_P.n22 FE_O_P.n20 0.189974
R1228 FE_O_P.n30 FE_O_P.n29 0.166289
R1229 FE_O_P.n5 FE_O_P.n0 0.1205
R1230 FE_O_P.n11 FE_O_P.n1 0.1205
R1231 FE_O_P.n25 FE_O_P.n24 0.0952368
R1232 FE_O_P.n25 FE_O_P.n22 0.0952368
R1233 FE_O_P.n12 FE_O_P.n0 0.0485
R1234 FE_O_P.n12 FE_O_P.n11 0.0485
R1235 FE_E_P.n16 FE_E_P.t17 113.632
R1236 FE_E_P.n13 FE_E_P.t14 113.632
R1237 FE_E_P.n6 FE_E_P.t18 113.632
R1238 FE_E_P.n2 FE_E_P.t25 113.632
R1239 FE_E_P.n14 FE_E_P.t15 109.174
R1240 FE_E_P.n15 FE_E_P.t16 109.174
R1241 FE_E_P.n7 FE_E_P.t19 109.174
R1242 FE_E_P.n8 FE_E_P.t20 109.174
R1243 FE_E_P.n9 FE_E_P.t21 109.174
R1244 FE_E_P.n10 FE_E_P.t22 109.174
R1245 FE_E_P.n4 FE_E_P.t23 109.174
R1246 FE_E_P.n3 FE_E_P.t24 109.174
R1247 FE_E_P FE_E_P.n18 77.1792
R1248 FE_E_P.n8 FE_E_P.n5 18.4942
R1249 FE_E_P.n9 FE_E_P.n0 18.4942
R1250 FE_E_P.n11 FE_E_P.n10 18.4942
R1251 FE_E_P.n4 FE_E_P.n1 18.4942
R1252 FE_E_P.n18 FE_E_P.n12 14.8701
R1253 FE_E_P.n15 FE_E_P.n14 11.6805
R1254 FE_E_P.n8 FE_E_P.n7 11.6805
R1255 FE_E_P.n9 FE_E_P.n8 11.6805
R1256 FE_E_P.n10 FE_E_P.n9 11.6805
R1257 FE_E_P.n10 FE_E_P.n4 11.6805
R1258 FE_E_P.n4 FE_E_P.n3 11.6805
R1259 FE_E_P FE_E_P.n31 11.3292
R1260 FE_E_P.n31 FE_E_P.n30 9.42986
R1261 FE_E_P.n18 FE_E_P.n17 9.0005
R1262 FE_E_P.n6 FE_E_P.n5 7.17687
R1263 FE_E_P.n2 FE_E_P.n1 7.17687
R1264 FE_E_P.n17 FE_E_P.n13 7.10487
R1265 FE_E_P.n17 FE_E_P.n16 7.10487
R1266 FE_E_P.n31 FE_E_P.n25 7.01407
R1267 FE_E_P.n27 FE_E_P.t1 5.7796
R1268 FE_E_P.n20 FE_E_P.t2 5.73764
R1269 FE_E_P.n22 FE_E_P.t9 5.73764
R1270 FE_E_P.n30 FE_E_P.t10 5.59012
R1271 FE_E_P.n29 FE_E_P.n28 5.38537
R1272 FE_E_P.n27 FE_E_P.n26 5.38537
R1273 FE_E_P.n20 FE_E_P.n19 5.32067
R1274 FE_E_P.n24 FE_E_P.n23 5.32067
R1275 FE_E_P.n22 FE_E_P.n21 5.32067
R1276 FE_E_P.n14 FE_E_P.n13 4.42851
R1277 FE_E_P.n16 FE_E_P.n15 4.42851
R1278 FE_E_P.n7 FE_E_P.n6 4.42851
R1279 FE_E_P.n3 FE_E_P.n2 4.42851
R1280 FE_E_P.n19 FE_E_P.t4 0.228
R1281 FE_E_P.n19 FE_E_P.t3 0.228
R1282 FE_E_P.n23 FE_E_P.t6 0.228
R1283 FE_E_P.n23 FE_E_P.t5 0.228
R1284 FE_E_P.n21 FE_E_P.t8 0.228
R1285 FE_E_P.n21 FE_E_P.t7 0.228
R1286 FE_E_P.n28 FE_E_P.t12 0.20525
R1287 FE_E_P.n28 FE_E_P.t11 0.20525
R1288 FE_E_P.n26 FE_E_P.t0 0.20525
R1289 FE_E_P.n26 FE_E_P.t13 0.20525
R1290 FE_E_P.n29 FE_E_P.n27 0.189974
R1291 FE_E_P.n30 FE_E_P.n29 0.189974
R1292 FE_E_P.n24 FE_E_P.n22 0.189974
R1293 FE_E_P.n5 FE_E_P.n0 0.1205
R1294 FE_E_P.n11 FE_E_P.n1 0.1205
R1295 FE_E_P.n25 FE_E_P.n24 0.0952368
R1296 FE_E_P.n25 FE_E_P.n20 0.0952368
R1297 FE_E_P.n12 FE_E_P.n0 0.0485
R1298 FE_E_P.n12 FE_E_P.n11 0.0485
R1299 FE_E_N.n16 FE_E_N.t17 113.632
R1300 FE_E_N.n13 FE_E_N.t14 113.632
R1301 FE_E_N.n6 FE_E_N.t18 113.632
R1302 FE_E_N.n2 FE_E_N.t25 113.632
R1303 FE_E_N.n14 FE_E_N.t15 109.174
R1304 FE_E_N.n15 FE_E_N.t16 109.174
R1305 FE_E_N.n7 FE_E_N.t19 109.174
R1306 FE_E_N.n8 FE_E_N.t20 109.174
R1307 FE_E_N.n9 FE_E_N.t21 109.174
R1308 FE_E_N.n10 FE_E_N.t22 109.174
R1309 FE_E_N.n4 FE_E_N.t23 109.174
R1310 FE_E_N.n3 FE_E_N.t24 109.174
R1311 FE_E_N.n32 FE_E_N.n18 74.6287
R1312 FE_E_N.n8 FE_E_N.n5 18.4942
R1313 FE_E_N.n9 FE_E_N.n0 18.4942
R1314 FE_E_N.n11 FE_E_N.n10 18.4942
R1315 FE_E_N.n4 FE_E_N.n1 18.4942
R1316 FE_E_N.n18 FE_E_N.n12 14.8701
R1317 FE_E_N.n15 FE_E_N.n14 11.6805
R1318 FE_E_N.n8 FE_E_N.n7 11.6805
R1319 FE_E_N.n9 FE_E_N.n8 11.6805
R1320 FE_E_N.n10 FE_E_N.n9 11.6805
R1321 FE_E_N.n10 FE_E_N.n4 11.6805
R1322 FE_E_N.n4 FE_E_N.n3 11.6805
R1323 FE_E_N.n32 FE_E_N.n31 10.9962
R1324 FE_E_N.n18 FE_E_N.n17 9.0005
R1325 FE_E_N.n31 FE_E_N.n30 8.81407
R1326 FE_E_N.n31 FE_E_N.n25 7.46407
R1327 FE_E_N.n6 FE_E_N.n5 7.17687
R1328 FE_E_N.n2 FE_E_N.n1 7.17687
R1329 FE_E_N.n17 FE_E_N.n13 7.10487
R1330 FE_E_N.n17 FE_E_N.n16 7.10487
R1331 FE_E_N.n27 FE_E_N.t0 5.7796
R1332 FE_E_N.n20 FE_E_N.t13 5.73764
R1333 FE_E_N.n22 FE_E_N.t3 5.73764
R1334 FE_E_N.n30 FE_E_N.t12 5.61381
R1335 FE_E_N.n27 FE_E_N.n26 5.38537
R1336 FE_E_N.n29 FE_E_N.n28 5.38537
R1337 FE_E_N.n20 FE_E_N.n19 5.32067
R1338 FE_E_N.n24 FE_E_N.n23 5.32067
R1339 FE_E_N.n22 FE_E_N.n21 5.32067
R1340 FE_E_N.n14 FE_E_N.n13 4.42851
R1341 FE_E_N.n16 FE_E_N.n15 4.42851
R1342 FE_E_N.n7 FE_E_N.n6 4.42851
R1343 FE_E_N.n3 FE_E_N.n2 4.42851
R1344 FE_E_N.n19 FE_E_N.t7 0.228
R1345 FE_E_N.n19 FE_E_N.t6 0.228
R1346 FE_E_N.n23 FE_E_N.t9 0.228
R1347 FE_E_N.n23 FE_E_N.t8 0.228
R1348 FE_E_N.n21 FE_E_N.t5 0.228
R1349 FE_E_N.n21 FE_E_N.t4 0.228
R1350 FE_E_N.n26 FE_E_N.t2 0.20525
R1351 FE_E_N.n26 FE_E_N.t1 0.20525
R1352 FE_E_N.n28 FE_E_N.t11 0.20525
R1353 FE_E_N.n28 FE_E_N.t10 0.20525
R1354 FE_E_N.n29 FE_E_N.n27 0.189974
R1355 FE_E_N.n24 FE_E_N.n22 0.189974
R1356 FE_E_N.n30 FE_E_N.n29 0.166289
R1357 FE_E_N.n5 FE_E_N.n0 0.1205
R1358 FE_E_N.n11 FE_E_N.n1 0.1205
R1359 FE_E_N.n25 FE_E_N.n24 0.0952368
R1360 FE_E_N.n25 FE_E_N.n20 0.0952368
R1361 FE_E_N.n12 FE_E_N.n0 0.0485
R1362 FE_E_N.n12 FE_E_N.n11 0.0485
R1363 FE_E_N FE_E_N.n32 0.0205
R1364 ODD_Q.n5 ODD_Q.n2 12.9918
R1365 ODD_Q ODD_Q.n5 10.5466
R1366 ODD_Q.n1 ODD_Q.t5 5.73764
R1367 ODD_Q.n2 ODD_Q.t3 5.6429
R1368 ODD_Q.n4 ODD_Q.t6 5.63749
R1369 ODD_Q.n4 ODD_Q.n3 5.52748
R1370 ODD_Q.n1 ODD_Q.n0 5.32067
R1371 ODD_Q.n5 ODD_Q.n4 4.61789
R1372 ODD_Q.n0 ODD_Q.t1 0.228
R1373 ODD_Q.n0 ODD_Q.t2 0.228
R1374 ODD_Q.n3 ODD_Q.t0 0.20525
R1375 ODD_Q.n3 ODD_Q.t4 0.20525
R1376 ODD_Q.n2 ODD_Q.n1 0.0952368
R1377 ODD_QB ODD_QB.n5 21.5031
R1378 ODD_QB.n5 ODD_QB.n2 12.7179
R1379 ODD_QB.n1 ODD_QB.t1 5.73764
R1380 ODD_QB.n2 ODD_QB.t0 5.6429
R1381 ODD_QB.n4 ODD_QB.t6 5.63749
R1382 ODD_QB.n4 ODD_QB.n3 5.52748
R1383 ODD_QB.n1 ODD_QB.n0 5.32067
R1384 ODD_QB.n5 ODD_QB.n4 4.8918
R1385 ODD_QB.n0 ODD_QB.t2 0.228
R1386 ODD_QB.n0 ODD_QB.t4 0.228
R1387 ODD_QB.n3 ODD_QB.t5 0.20525
R1388 ODD_QB.n3 ODD_QB.t3 0.20525
R1389 ODD_QB.n2 ODD_QB.n1 0.0952368
R1390 EVEN_QB EVEN_QB.n5 20.9553
R1391 EVEN_QB.n5 EVEN_QB.n2 13.1092
R1392 EVEN_QB.n1 EVEN_QB.t6 5.73764
R1393 EVEN_QB.n2 EVEN_QB.t0 5.6429
R1394 EVEN_QB.n4 EVEN_QB.t1 5.63749
R1395 EVEN_QB.n4 EVEN_QB.n3 5.52748
R1396 EVEN_QB.n1 EVEN_QB.n0 5.32067
R1397 EVEN_QB.n5 EVEN_QB.n4 4.5005
R1398 EVEN_QB.n0 EVEN_QB.t2 0.228
R1399 EVEN_QB.n0 EVEN_QB.t3 0.228
R1400 EVEN_QB.n3 EVEN_QB.t4 0.20525
R1401 EVEN_QB.n3 EVEN_QB.t5 0.20525
R1402 EVEN_QB.n2 EVEN_QB.n1 0.0952368
R1403 EVEN_Q.n5 EVEN_Q.n2 13.1092
R1404 EVEN_Q EVEN_Q.n5 11.0553
R1405 EVEN_Q.n1 EVEN_Q.t0 5.73764
R1406 EVEN_Q.n2 EVEN_Q.t5 5.6429
R1407 EVEN_Q.n4 EVEN_Q.t6 5.63749
R1408 EVEN_Q.n4 EVEN_Q.n3 5.52748
R1409 EVEN_Q.n1 EVEN_Q.n0 5.32067
R1410 EVEN_Q.n5 EVEN_Q.n4 4.5005
R1411 EVEN_Q.n0 EVEN_Q.t1 0.228
R1412 EVEN_Q.n0 EVEN_Q.t2 0.228
R1413 EVEN_Q.n3 EVEN_Q.t3 0.20525
R1414 EVEN_Q.n3 EVEN_Q.t4 0.20525
R1415 EVEN_Q.n2 EVEN_Q.n1 0.0952368
R1416 O_CAPTURE_CLKB.n17 O_CAPTURE_CLKB.t0 113.632
R1417 O_CAPTURE_CLKB.n5 O_CAPTURE_CLKB.t8 113.632
R1418 O_CAPTURE_CLKB.n26 O_CAPTURE_CLKB.t7 109.174
R1419 O_CAPTURE_CLKB.n25 O_CAPTURE_CLKB.t6 109.174
R1420 O_CAPTURE_CLKB.n24 O_CAPTURE_CLKB.t5 109.174
R1421 O_CAPTURE_CLKB.n15 O_CAPTURE_CLKB.t4 109.174
R1422 O_CAPTURE_CLKB.n20 O_CAPTURE_CLKB.t3 109.174
R1423 O_CAPTURE_CLKB.n19 O_CAPTURE_CLKB.t2 109.174
R1424 O_CAPTURE_CLKB.n18 O_CAPTURE_CLKB.t1 109.174
R1425 O_CAPTURE_CLKB.n6 O_CAPTURE_CLKB.t9 109.174
R1426 O_CAPTURE_CLKB.n7 O_CAPTURE_CLKB.t10 109.174
R1427 O_CAPTURE_CLKB.n8 O_CAPTURE_CLKB.t11 109.174
R1428 O_CAPTURE_CLKB.n9 O_CAPTURE_CLKB.t12 109.174
R1429 O_CAPTURE_CLKB.n10 O_CAPTURE_CLKB.t13 109.174
R1430 O_CAPTURE_CLKB.n11 O_CAPTURE_CLKB.t14 109.174
R1431 O_CAPTURE_CLKB.n12 O_CAPTURE_CLKB.t15 109.174
R1432 O_CAPTURE_CLKB O_CAPTURE_CLKB.n28 47.0442
R1433 O_CAPTURE_CLKB.n27 O_CAPTURE_CLKB.n26 18.4942
R1434 O_CAPTURE_CLKB.n25 O_CAPTURE_CLKB.n14 18.4942
R1435 O_CAPTURE_CLKB.n24 O_CAPTURE_CLKB.n23 18.4942
R1436 O_CAPTURE_CLKB.n22 O_CAPTURE_CLKB.n15 18.4942
R1437 O_CAPTURE_CLKB.n21 O_CAPTURE_CLKB.n20 18.4942
R1438 O_CAPTURE_CLKB.n19 O_CAPTURE_CLKB.n16 18.4942
R1439 O_CAPTURE_CLKB.n7 O_CAPTURE_CLKB.n4 18.4942
R1440 O_CAPTURE_CLKB.n8 O_CAPTURE_CLKB.n3 18.4942
R1441 O_CAPTURE_CLKB.n9 O_CAPTURE_CLKB.n2 18.4942
R1442 O_CAPTURE_CLKB.n10 O_CAPTURE_CLKB.n1 18.4942
R1443 O_CAPTURE_CLKB.n11 O_CAPTURE_CLKB.n0 18.4942
R1444 O_CAPTURE_CLKB.n13 O_CAPTURE_CLKB.n12 18.4942
R1445 O_CAPTURE_CLKB.n28 O_CAPTURE_CLKB.n13 14.2555
R1446 O_CAPTURE_CLKB.n26 O_CAPTURE_CLKB.n25 11.6805
R1447 O_CAPTURE_CLKB.n25 O_CAPTURE_CLKB.n24 11.6805
R1448 O_CAPTURE_CLKB.n24 O_CAPTURE_CLKB.n15 11.6805
R1449 O_CAPTURE_CLKB.n20 O_CAPTURE_CLKB.n15 11.6805
R1450 O_CAPTURE_CLKB.n20 O_CAPTURE_CLKB.n19 11.6805
R1451 O_CAPTURE_CLKB.n19 O_CAPTURE_CLKB.n18 11.6805
R1452 O_CAPTURE_CLKB.n7 O_CAPTURE_CLKB.n6 11.6805
R1453 O_CAPTURE_CLKB.n8 O_CAPTURE_CLKB.n7 11.6805
R1454 O_CAPTURE_CLKB.n9 O_CAPTURE_CLKB.n8 11.6805
R1455 O_CAPTURE_CLKB.n10 O_CAPTURE_CLKB.n9 11.6805
R1456 O_CAPTURE_CLKB.n11 O_CAPTURE_CLKB.n10 11.6805
R1457 O_CAPTURE_CLKB.n12 O_CAPTURE_CLKB.n11 11.6805
R1458 O_CAPTURE_CLKB.n28 O_CAPTURE_CLKB.n27 9.1685
R1459 O_CAPTURE_CLKB.n17 O_CAPTURE_CLKB.n16 7.17687
R1460 O_CAPTURE_CLKB.n5 O_CAPTURE_CLKB.n4 7.17687
R1461 O_CAPTURE_CLKB.n18 O_CAPTURE_CLKB.n17 4.42851
R1462 O_CAPTURE_CLKB.n6 O_CAPTURE_CLKB.n5 4.42851
R1463 O_CAPTURE_CLKB.n27 O_CAPTURE_CLKB.n14 0.1205
R1464 O_CAPTURE_CLKB.n23 O_CAPTURE_CLKB.n14 0.1205
R1465 O_CAPTURE_CLKB.n23 O_CAPTURE_CLKB.n22 0.1205
R1466 O_CAPTURE_CLKB.n22 O_CAPTURE_CLKB.n21 0.1205
R1467 O_CAPTURE_CLKB.n21 O_CAPTURE_CLKB.n16 0.1205
R1468 O_CAPTURE_CLKB.n13 O_CAPTURE_CLKB.n0 0.1205
R1469 O_CAPTURE_CLKB.n1 O_CAPTURE_CLKB.n0 0.1205
R1470 O_CAPTURE_CLKB.n2 O_CAPTURE_CLKB.n1 0.1205
R1471 O_CAPTURE_CLKB.n3 O_CAPTURE_CLKB.n2 0.1205
R1472 O_CAPTURE_CLKB.n4 O_CAPTURE_CLKB.n3 0.1205
R1473 E_CAPTURE_CLKB.n17 E_CAPTURE_CLKB.t0 113.632
R1474 E_CAPTURE_CLKB.n5 E_CAPTURE_CLKB.t8 113.632
R1475 E_CAPTURE_CLKB.n26 E_CAPTURE_CLKB.t7 109.174
R1476 E_CAPTURE_CLKB.n25 E_CAPTURE_CLKB.t6 109.174
R1477 E_CAPTURE_CLKB.n24 E_CAPTURE_CLKB.t5 109.174
R1478 E_CAPTURE_CLKB.n15 E_CAPTURE_CLKB.t4 109.174
R1479 E_CAPTURE_CLKB.n20 E_CAPTURE_CLKB.t3 109.174
R1480 E_CAPTURE_CLKB.n19 E_CAPTURE_CLKB.t2 109.174
R1481 E_CAPTURE_CLKB.n18 E_CAPTURE_CLKB.t1 109.174
R1482 E_CAPTURE_CLKB.n6 E_CAPTURE_CLKB.t9 109.174
R1483 E_CAPTURE_CLKB.n7 E_CAPTURE_CLKB.t10 109.174
R1484 E_CAPTURE_CLKB.n8 E_CAPTURE_CLKB.t11 109.174
R1485 E_CAPTURE_CLKB.n9 E_CAPTURE_CLKB.t12 109.174
R1486 E_CAPTURE_CLKB.n10 E_CAPTURE_CLKB.t13 109.174
R1487 E_CAPTURE_CLKB.n11 E_CAPTURE_CLKB.t14 109.174
R1488 E_CAPTURE_CLKB.n12 E_CAPTURE_CLKB.t15 109.174
R1489 E_CAPTURE_CLKB E_CAPTURE_CLKB.n28 29.0413
R1490 E_CAPTURE_CLKB.n27 E_CAPTURE_CLKB.n26 18.4942
R1491 E_CAPTURE_CLKB.n25 E_CAPTURE_CLKB.n14 18.4942
R1492 E_CAPTURE_CLKB.n24 E_CAPTURE_CLKB.n23 18.4942
R1493 E_CAPTURE_CLKB.n22 E_CAPTURE_CLKB.n15 18.4942
R1494 E_CAPTURE_CLKB.n21 E_CAPTURE_CLKB.n20 18.4942
R1495 E_CAPTURE_CLKB.n19 E_CAPTURE_CLKB.n16 18.4942
R1496 E_CAPTURE_CLKB.n7 E_CAPTURE_CLKB.n4 18.4942
R1497 E_CAPTURE_CLKB.n8 E_CAPTURE_CLKB.n3 18.4942
R1498 E_CAPTURE_CLKB.n9 E_CAPTURE_CLKB.n2 18.4942
R1499 E_CAPTURE_CLKB.n10 E_CAPTURE_CLKB.n1 18.4942
R1500 E_CAPTURE_CLKB.n11 E_CAPTURE_CLKB.n0 18.4942
R1501 E_CAPTURE_CLKB.n13 E_CAPTURE_CLKB.n12 18.4942
R1502 E_CAPTURE_CLKB.n28 E_CAPTURE_CLKB.n13 14.2555
R1503 E_CAPTURE_CLKB.n26 E_CAPTURE_CLKB.n25 11.6805
R1504 E_CAPTURE_CLKB.n25 E_CAPTURE_CLKB.n24 11.6805
R1505 E_CAPTURE_CLKB.n24 E_CAPTURE_CLKB.n15 11.6805
R1506 E_CAPTURE_CLKB.n20 E_CAPTURE_CLKB.n15 11.6805
R1507 E_CAPTURE_CLKB.n20 E_CAPTURE_CLKB.n19 11.6805
R1508 E_CAPTURE_CLKB.n19 E_CAPTURE_CLKB.n18 11.6805
R1509 E_CAPTURE_CLKB.n7 E_CAPTURE_CLKB.n6 11.6805
R1510 E_CAPTURE_CLKB.n8 E_CAPTURE_CLKB.n7 11.6805
R1511 E_CAPTURE_CLKB.n9 E_CAPTURE_CLKB.n8 11.6805
R1512 E_CAPTURE_CLKB.n10 E_CAPTURE_CLKB.n9 11.6805
R1513 E_CAPTURE_CLKB.n11 E_CAPTURE_CLKB.n10 11.6805
R1514 E_CAPTURE_CLKB.n12 E_CAPTURE_CLKB.n11 11.6805
R1515 E_CAPTURE_CLKB.n28 E_CAPTURE_CLKB.n27 9.1685
R1516 E_CAPTURE_CLKB.n17 E_CAPTURE_CLKB.n16 7.17687
R1517 E_CAPTURE_CLKB.n5 E_CAPTURE_CLKB.n4 7.17687
R1518 E_CAPTURE_CLKB.n18 E_CAPTURE_CLKB.n17 4.42851
R1519 E_CAPTURE_CLKB.n6 E_CAPTURE_CLKB.n5 4.42851
R1520 E_CAPTURE_CLKB.n27 E_CAPTURE_CLKB.n14 0.1205
R1521 E_CAPTURE_CLKB.n23 E_CAPTURE_CLKB.n14 0.1205
R1522 E_CAPTURE_CLKB.n23 E_CAPTURE_CLKB.n22 0.1205
R1523 E_CAPTURE_CLKB.n22 E_CAPTURE_CLKB.n21 0.1205
R1524 E_CAPTURE_CLKB.n21 E_CAPTURE_CLKB.n16 0.1205
R1525 E_CAPTURE_CLKB.n13 E_CAPTURE_CLKB.n0 0.1205
R1526 E_CAPTURE_CLKB.n1 E_CAPTURE_CLKB.n0 0.1205
R1527 E_CAPTURE_CLKB.n2 E_CAPTURE_CLKB.n1 0.1205
R1528 E_CAPTURE_CLKB.n3 E_CAPTURE_CLKB.n2 0.1205
R1529 E_CAPTURE_CLKB.n4 E_CAPTURE_CLKB.n3 0.1205
R1530 VDD.t366 VDD.t365 2823.53
R1531 VDD.t368 VDD.t367 2823.53
R1532 VDD.t367 VDD.t366 1411.76
R1533 VDD.n5 VDD.t369 923.077
R1534 VDD.n6 VDD.t505 923.077
R1535 VDD.n10 VDD.t509 923.077
R1536 VDD.n11 VDD.t4 923.077
R1537 VDD.n15 VDD.t105 923.077
R1538 VDD.n16 VDD.t125 923.077
R1539 VDD.t508 VDD.t371 640.625
R1540 VDD.t512 VDD.t507 640.625
R1541 VDD.t7 VDD.t511 640.625
R1542 VDD.t108 VDD.t6 640.625
R1543 VDD.t128 VDD.t107 640.625
R1544 VDD.t194 VDD.t127 640.625
R1545 VDD.n3 VDD.t369 483.238
R1546 VDD.t505 VDD.n5 461.538
R1547 VDD.n6 VDD.t509 461.538
R1548 VDD.t4 VDD.n10 461.538
R1549 VDD.n11 VDD.t105 461.538
R1550 VDD.t125 VDD.n15 461.538
R1551 VDD.n16 VDD.t191 461.538
R1552 VDD.n38 VDD.t368 407.682
R1553 VDD.n19 VDD.t193 313.457
R1554 VDD.n348 VDD.n347 166.667
R1555 VDD.n348 VDD.n333 166.667
R1556 VDD.n365 VDD.n306 166.667
R1557 VDD.n371 VDD.n306 166.667
R1558 VDD.n110 VDD.n109 166.667
R1559 VDD.n110 VDD.n53 166.667
R1560 VDD.n83 VDD.n82 166.667
R1561 VDD.n82 VDD.n66 166.667
R1562 VDD.n270 VDD.n267 166.667
R1563 VDD.n267 VDD.n266 166.667
R1564 VDD.n347 VDD.t440 143.333
R1565 VDD.t177 VDD.n371 143.333
R1566 VDD.n109 VDD.t389 143.333
R1567 VDD.t487 VDD.n66 143.333
R1568 VDD.t12 VDD.n268 126.668
R1569 VDD.n257 VDD.t16 126.668
R1570 VDD.t2 VDD.n292 113.334
R1571 VDD.n284 VDD.t72 113.334
R1572 VDD.t78 VDD.n251 113.334
R1573 VDD.n243 VDD.t463 113.334
R1574 VDD.n341 VDD.n340 106.3
R1575 VDD.n304 VDD.n302 106.3
R1576 VDD.n120 VDD.n119 106.3
R1577 VDD.n73 VDD.n72 106.3
R1578 VDD.n295 VDD.n294 106.3
R1579 VDD.n240 VDD.n239 106.3
R1580 VDD.n334 VDD.t273 93.3338
R1581 VDD.n364 VDD.t277 93.3338
R1582 VDD.n106 VDD.t547 93.3338
R1583 VDD.n84 VDD.t521 93.3338
R1584 VDD.n346 VDD.t173 86.6672
R1585 VDD.t424 VDD.n372 86.6672
R1586 VDD.t383 VDD.n118 86.6672
R1587 VDD.n74 VDD.t113 86.6672
R1588 VDD.n341 VDD.n337 70.0005
R1589 VDD.n345 VDD.n337 70.0005
R1590 VDD.n345 VDD.n332 70.0005
R1591 VDD.n349 VDD.n332 70.0005
R1592 VDD.n349 VDD.n326 70.0005
R1593 VDD.n353 VDD.n326 70.0005
R1594 VDD.n353 VDD.n324 70.0005
R1595 VDD.n356 VDD.n324 70.0005
R1596 VDD.n356 VDD.n316 70.0005
R1597 VDD.n360 VDD.n316 70.0005
R1598 VDD.n360 VDD.n315 70.0005
R1599 VDD.n315 VDD.n312 70.0005
R1600 VDD.n366 VDD.n312 70.0005
R1601 VDD.n366 VDD.n307 70.0005
R1602 VDD.n370 VDD.n307 70.0005
R1603 VDD.n370 VDD.n303 70.0005
R1604 VDD.n373 VDD.n303 70.0005
R1605 VDD.n373 VDD.n302 70.0005
R1606 VDD.n120 VDD.n47 70.0005
R1607 VDD.n117 VDD.n47 70.0005
R1608 VDD.n117 VDD.n48 70.0005
R1609 VDD.n111 VDD.n48 70.0005
R1610 VDD.n111 VDD.n52 70.0005
R1611 VDD.n104 VDD.n52 70.0005
R1612 VDD.n104 VDD.n55 70.0005
R1613 VDD.n98 VDD.n55 70.0005
R1614 VDD.n98 VDD.n59 70.0005
R1615 VDD.n95 VDD.n59 70.0005
R1616 VDD.n95 VDD.n60 70.0005
R1617 VDD.n89 VDD.n60 70.0005
R1618 VDD.n89 VDD.n64 70.0005
R1619 VDD.n81 VDD.n64 70.0005
R1620 VDD.n81 VDD.n67 70.0005
R1621 VDD.n75 VDD.n67 70.0005
R1622 VDD.n75 VDD.n71 70.0005
R1623 VDD.n72 VDD.n71 70.0005
R1624 VDD.n295 VDD.n216 70.0005
R1625 VDD.n291 VDD.n216 70.0005
R1626 VDD.n291 VDD.n217 70.0005
R1627 VDD.n285 VDD.n217 70.0005
R1628 VDD.n285 VDD.n221 70.0005
R1629 VDD.n277 VDD.n221 70.0005
R1630 VDD.n277 VDD.n223 70.0005
R1631 VDD.n271 VDD.n223 70.0005
R1632 VDD.n271 VDD.n227 70.0005
R1633 VDD.n265 VDD.n227 70.0005
R1634 VDD.n265 VDD.n228 70.0005
R1635 VDD.n259 VDD.n228 70.0005
R1636 VDD.n259 VDD.n232 70.0005
R1637 VDD.n250 VDD.n232 70.0005
R1638 VDD.n250 VDD.n234 70.0005
R1639 VDD.n244 VDD.n234 70.0005
R1640 VDD.n244 VDD.n238 70.0005
R1641 VDD.n239 VDD.n238 70.0005
R1642 VDD.n334 VDD.n333 66.6672
R1643 VDD.n365 VDD.n364 66.6672
R1644 VDD.n106 VDD.n53 66.6672
R1645 VDD.n84 VDD.n83 66.6672
R1646 VDD.n294 VDD.n293 66.6672
R1647 VDD.n280 VDD.n279 66.6672
R1648 VDD.n253 VDD.n252 66.6672
R1649 VDD.n241 VDD.n240 66.6672
R1650 VDD.t371 VDD.t372 62.5005
R1651 VDD.t507 VDD.t508 62.5005
R1652 VDD.t511 VDD.t512 62.5005
R1653 VDD.t6 VDD.t7 62.5005
R1654 VDD.t107 VDD.t108 62.5005
R1655 VDD.t127 VDD.t128 62.5005
R1656 VDD.t193 VDD.t194 62.5005
R1657 VDD.n340 VDD.t189 53.3338
R1658 VDD.t249 VDD.t56 53.3338
R1659 VDD.t56 VDD.t261 53.3338
R1660 VDD.t266 VDD.t54 53.3338
R1661 VDD.t54 VDD.t245 53.3338
R1662 VDD.t438 VDD.n304 53.3338
R1663 VDD.n119 VDD.t373 53.3338
R1664 VDD.t529 VDD.t52 53.3338
R1665 VDD.t52 VDD.t531 53.3338
R1666 VDD.t536 VDD.t50 53.3338
R1667 VDD.t50 VDD.t537 53.3338
R1668 VDD.t279 VDD.n73 53.3338
R1669 VDD.n283 VDD.t483 53.3338
R1670 VDD.t564 VDD.n283 53.3338
R1671 VDD.n280 VDD.t347 53.3338
R1672 VDD.n253 VDD.t96 53.3338
R1673 VDD.n242 VDD.t46 53.3338
R1674 VDD.t152 VDD.n242 53.3338
R1675 VDD.n268 VDD.t513 46.6672
R1676 VDD.t203 VDD.n257 46.6672
R1677 VDD.t299 VDD.t357 33.3338
R1678 VDD.t82 VDD.t301 33.3338
R1679 VDD.n270 VDD.t10 26.6672
R1680 VDD.n266 VDD.t561 26.6672
R1681 VDD.n515 VDD.n514 25.203
R1682 VDD.n551 VDD.n550 25.203
R1683 VDD.n31 VDD.t68 25.1121
R1684 VDD.n33 VDD.t202 24.7565
R1685 VDD.n37 VDD.t467 24.7565
R1686 VDD.n34 VDD.t18 24.7565
R1687 VDD.n456 VDD.n455 24.4328
R1688 VDD.n402 VDD.n401 24.4328
R1689 VDD.n135 VDD.n134 24.4328
R1690 VDD.n202 VDD.n201 24.4328
R1691 VDD.n21 VDD.t138 22.412
R1692 VDD.n378 VDD.n377 22.1797
R1693 VDD.n393 VDD.n392 22.1797
R1694 VDD.n137 VDD.n136 22.1797
R1695 VDD.n124 VDD.n123 22.1797
R1696 VDD.n538 VDD.n537 22.1735
R1697 VDD.n28 VDD.t169 22.1461
R1698 VDD.n22 VDD.t9 21.9835
R1699 VDD.n39 VDD.t139 21.9006
R1700 VDD.n40 VDD.t48 21.9006
R1701 VDD.n25 VDD.t196 21.7356
R1702 VDD.n24 VDD.t8 21.7356
R1703 VDD.n21 VDD.t49 21.612
R1704 VDD.n17 VDD.n16 21.6005
R1705 VDD.n15 VDD.n14 21.6005
R1706 VDD.n12 VDD.n11 21.6005
R1707 VDD.n10 VDD.n9 21.6005
R1708 VDD.n7 VDD.n6 21.6005
R1709 VDD.n5 VDD.n4 21.6005
R1710 VDD.n22 VDD.t31 21.5835
R1711 VDD.n39 VDD.t170 21.545
R1712 VDD.n40 VDD.t197 21.545
R1713 VDD.n36 VDD.t195 21.4505
R1714 VDD.n35 VDD.t468 21.4505
R1715 VDD.n28 VDD.t137 21.435
R1716 VDD.n30 VDD.t136 21.435
R1717 VDD.n29 VDD.t168 21.435
R1718 VDD.n32 VDD.t70 21.3935
R1719 VDD.n31 VDD.t69 21.3935
R1720 VDD.n25 VDD.t563 21.38
R1721 VDD.n24 VDD.t470 21.38
R1722 VDD.n292 VDD.t471 20.0005
R1723 VDD.n284 VDD.t578 20.0005
R1724 VDD.n251 VDD.t36 20.0005
R1725 VDD.n243 VDD.t163 20.0005
R1726 VDD.n500 VDD.n493 19.5039
R1727 VDD.n569 VDD.n562 19.5039
R1728 VDD.n405 VDD.n403 19.4916
R1729 VDD.n200 VDD.n199 19.4916
R1730 VDD.n454 VDD.n453 19.4916
R1731 VDD.n140 VDD.n138 19.4916
R1732 VDD.n506 VDD.n504 19.4092
R1733 VDD.n513 VDD.n512 19.4092
R1734 VDD.n554 VDD.n552 19.4092
R1735 VDD.n561 VDD.n560 19.4092
R1736 VDD.n465 VDD.n464 19.0179
R1737 VDD.n463 VDD.n457 19.0179
R1738 VDD.n205 VDD.n203 19.0179
R1739 VDD.n211 VDD.n210 19.0179
R1740 VDD.n297 VDD.n296 18.3116
R1741 VDD.n376 VDD.n299 18.1338
R1742 VDD.n122 VDD.n121 18.1338
R1743 VDD.n344 VDD.n339 18.0005
R1744 VDD.n338 VDD.n331 18.0005
R1745 VDD.n350 VDD.n330 18.0005
R1746 VDD.n351 VDD.n329 18.0005
R1747 VDD.n352 VDD.n328 18.0005
R1748 VDD.n327 VDD.n323 18.0005
R1749 VDD.n357 VDD.n322 18.0005
R1750 VDD.n358 VDD.n321 18.0005
R1751 VDD.n359 VDD.n320 18.0005
R1752 VDD.n319 VDD.n317 18.0005
R1753 VDD.n318 VDD.n311 18.0005
R1754 VDD.n367 VDD.n310 18.0005
R1755 VDD.n368 VDD.n309 18.0005
R1756 VDD.n369 VDD.n308 18.0005
R1757 VDD.n301 VDD.n300 18.0005
R1758 VDD.n375 VDD.n374 18.0005
R1759 VDD.n46 VDD.n45 18.0005
R1760 VDD.n116 VDD.n115 18.0005
R1761 VDD.n114 VDD.n49 18.0005
R1762 VDD.n113 VDD.n112 18.0005
R1763 VDD.n51 VDD.n50 18.0005
R1764 VDD.n103 VDD.n102 18.0005
R1765 VDD.n101 VDD.n56 18.0005
R1766 VDD.n100 VDD.n99 18.0005
R1767 VDD.n58 VDD.n57 18.0005
R1768 VDD.n94 VDD.n93 18.0005
R1769 VDD.n92 VDD.n61 18.0005
R1770 VDD.n91 VDD.n90 18.0005
R1771 VDD.n63 VDD.n62 18.0005
R1772 VDD.n80 VDD.n79 18.0005
R1773 VDD.n78 VDD.n68 18.0005
R1774 VDD.n77 VDD.n76 18.0005
R1775 VDD.n215 VDD.n214 18.0005
R1776 VDD.n290 VDD.n289 18.0005
R1777 VDD.n288 VDD.n218 18.0005
R1778 VDD.n287 VDD.n286 18.0005
R1779 VDD.n220 VDD.n219 18.0005
R1780 VDD.n276 VDD.n275 18.0005
R1781 VDD.n274 VDD.n224 18.0005
R1782 VDD.n273 VDD.n272 18.0005
R1783 VDD.n226 VDD.n225 18.0005
R1784 VDD.n264 VDD.n263 18.0005
R1785 VDD.n262 VDD.n229 18.0005
R1786 VDD.n261 VDD.n260 18.0005
R1787 VDD.n231 VDD.n230 18.0005
R1788 VDD.n249 VDD.n248 18.0005
R1789 VDD.n247 VDD.n235 18.0005
R1790 VDD.n246 VDD.n245 18.0005
R1791 VDD.n340 VDD.n336 17.6849
R1792 VDD.n73 VDD.n65 17.6847
R1793 VDD.n240 VDD.n233 17.6847
R1794 VDD.n524 VDD.n516 16.9481
R1795 VDD.n294 VDD.n213 16.4744
R1796 VDD.n347 VDD.n336 16.4218
R1797 VDD.n335 VDD.n334 16.4218
R1798 VDD.n355 VDD.n313 16.4218
R1799 VDD.n362 VDD.n361 16.4218
R1800 VDD.n364 VDD.n363 16.4218
R1801 VDD.n371 VDD.n305 16.4218
R1802 VDD.n119 VDD.n44 16.4218
R1803 VDD.n109 VDD.n108 16.4218
R1804 VDD.n107 VDD.n106 16.4218
R1805 VDD.n97 VDD.n54 16.4218
R1806 VDD.n87 VDD.n86 16.4218
R1807 VDD.n85 VDD.n84 16.4218
R1808 VDD.n66 VDD.n65 16.4218
R1809 VDD.n283 VDD.n282 16.4218
R1810 VDD.n281 VDD.n280 16.4218
R1811 VDD.n269 VDD.n222 16.4218
R1812 VDD.n256 VDD.n255 16.4218
R1813 VDD.n254 VDD.n253 16.4218
R1814 VDD.n242 VDD.n233 16.4218
R1815 VDD.n304 VDD.n298 16.4215
R1816 VDD.n437 VDD.n428 14.8005
R1817 VDD.n424 VDD.n415 14.8005
R1818 VDD.n167 VDD.n158 14.8005
R1819 VDD.n180 VDD.n171 14.8005
R1820 VDD.n493 VDD.n492 14.6703
R1821 VDD.n418 VDD.n414 14.6065
R1822 VDD.n160 VDD.n157 14.6065
R1823 VDD.n488 VDD.n484 13.7564
R1824 VDD.n576 VDD.n575 13.4387
R1825 VDD.t189 VDD.t187 13.3338
R1826 VDD.t187 VDD.t185 13.3338
R1827 VDD.t185 VDD.t183 13.3338
R1828 VDD.t183 VDD.t181 13.3338
R1829 VDD.t181 VDD.t179 13.3338
R1830 VDD.t179 VDD.t175 13.3338
R1831 VDD.t175 VDD.t173 13.3338
R1832 VDD.t440 VDD.t442 13.3338
R1833 VDD.t403 VDD.t420 13.3338
R1834 VDD.t401 VDD.t403 13.3338
R1835 VDD.t221 VDD.t219 13.3338
R1836 VDD.t217 VDD.t221 13.3338
R1837 VDD.t215 VDD.t217 13.3338
R1838 VDD.t166 VDD.t167 13.3338
R1839 VDD.t498 VDD.t166 13.3338
R1840 VDD.t497 VDD.t498 13.3338
R1841 VDD.t496 VDD.t497 13.3338
R1842 VDD.t135 VDD.t496 13.3338
R1843 VDD.t134 VDD.t135 13.3338
R1844 VDD.t133 VDD.t134 13.3338
R1845 VDD.t251 VDD.t243 13.3338
R1846 VDD.t253 VDD.t251 13.3338
R1847 VDD.t21 VDD.t253 13.3338
R1848 VDD.t257 VDD.t23 13.3338
R1849 VDD.t259 VDD.t257 13.3338
R1850 VDD.t259 VDD.t249 13.3338
R1851 VDD.t261 VDD.t262 13.3338
R1852 VDD.t262 VDD.t263 13.3338
R1853 VDD.t263 VDD.t25 13.3338
R1854 VDD.t26 VDD.t264 13.3338
R1855 VDD.t264 VDD.t265 13.3338
R1856 VDD.t265 VDD.t266 13.3338
R1857 VDD.t241 VDD.t245 13.3338
R1858 VDD.t267 VDD.t241 13.3338
R1859 VDD.t27 VDD.t267 13.3338
R1860 VDD.t247 VDD.t29 13.3338
R1861 VDD.t275 VDD.t247 13.3338
R1862 VDD.t271 VDD.t275 13.3338
R1863 VDD.t399 VDD.t400 13.3338
R1864 VDD.t412 VDD.t399 13.3338
R1865 VDD.t411 VDD.t412 13.3338
R1866 VDD.t298 VDD.t411 13.3338
R1867 VDD.t297 VDD.t298 13.3338
R1868 VDD.t293 VDD.t297 13.3338
R1869 VDD.t293 VDD.t292 13.3338
R1870 VDD.t223 VDD.t213 13.3338
R1871 VDD.t213 VDD.t225 13.3338
R1872 VDD.t225 VDD.t227 13.3338
R1873 VDD.t64 VDD.t62 13.3338
R1874 VDD.t62 VDD.t559 13.3338
R1875 VDD.t171 VDD.t177 13.3338
R1876 VDD.t428 VDD.t424 13.3338
R1877 VDD.t426 VDD.t428 13.3338
R1878 VDD.t436 VDD.t426 13.3338
R1879 VDD.t434 VDD.t436 13.3338
R1880 VDD.t432 VDD.t434 13.3338
R1881 VDD.t430 VDD.t432 13.3338
R1882 VDD.t430 VDD.t438 13.3338
R1883 VDD.t373 VDD.t381 13.3338
R1884 VDD.t381 VDD.t379 13.3338
R1885 VDD.t379 VDD.t377 13.3338
R1886 VDD.t377 VDD.t375 13.3338
R1887 VDD.t375 VDD.t387 13.3338
R1888 VDD.t387 VDD.t385 13.3338
R1889 VDD.t385 VDD.t383 13.3338
R1890 VDD.t389 VDD.t391 13.3338
R1891 VDD.t451 VDD.t453 13.3338
R1892 VDD.t494 VDD.t451 13.3338
R1893 VDD.t323 VDD.t329 13.3338
R1894 VDD.t313 VDD.t323 13.3338
R1895 VDD.t331 VDD.t313 13.3338
R1896 VDD.t295 VDD.t296 13.3338
R1897 VDD.t291 VDD.t295 13.3338
R1898 VDD.t290 VDD.t291 13.3338
R1899 VDD.t289 VDD.t290 13.3338
R1900 VDD.t419 VDD.t289 13.3338
R1901 VDD.t418 VDD.t419 13.3338
R1902 VDD.t417 VDD.t418 13.3338
R1903 VDD.t517 VDD.t515 13.3338
R1904 VDD.t519 VDD.t517 13.3338
R1905 VDD.t115 VDD.t519 13.3338
R1906 VDD.t525 VDD.t117 13.3338
R1907 VDD.t527 VDD.t525 13.3338
R1908 VDD.t527 VDD.t529 13.3338
R1909 VDD.t531 VDD.t532 13.3338
R1910 VDD.t532 VDD.t533 13.3338
R1911 VDD.t533 VDD.t119 13.3338
R1912 VDD.t120 VDD.t534 13.3338
R1913 VDD.t534 VDD.t535 13.3338
R1914 VDD.t535 VDD.t536 13.3338
R1915 VDD.t537 VDD.t541 13.3338
R1916 VDD.t541 VDD.t543 13.3338
R1917 VDD.t123 VDD.t543 13.3338
R1918 VDD.t549 VDD.t121 13.3338
R1919 VDD.t551 VDD.t549 13.3338
R1920 VDD.t553 VDD.t551 13.3338
R1921 VDD.t446 VDD.t444 13.3338
R1922 VDD.t445 VDD.t446 13.3338
R1923 VDD.t448 VDD.t445 13.3338
R1924 VDD.t447 VDD.t448 13.3338
R1925 VDD.t450 VDD.t447 13.3338
R1926 VDD.t449 VDD.t450 13.3338
R1927 VDD.t491 VDD.t449 13.3338
R1928 VDD.t311 VDD.t315 13.3338
R1929 VDD.t333 VDD.t311 13.3338
R1930 VDD.t335 VDD.t333 13.3338
R1931 VDD.t405 VDD.t407 13.3338
R1932 VDD.t76 VDD.t405 13.3338
R1933 VDD.t485 VDD.t487 13.3338
R1934 VDD.t113 VDD.t111 13.3338
R1935 VDD.t111 VDD.t109 13.3338
R1936 VDD.t109 VDD.t287 13.3338
R1937 VDD.t287 VDD.t285 13.3338
R1938 VDD.t285 VDD.t283 13.3338
R1939 VDD.t283 VDD.t281 13.3338
R1940 VDD.t281 VDD.t279 13.3338
R1941 VDD.n293 VDD.t465 13.3338
R1942 VDD.t465 VDD.t19 13.3338
R1943 VDD.t19 VDD.t148 13.3338
R1944 VDD.t148 VDD.t2 13.3338
R1945 VDD.t473 VDD.t471 13.3338
R1946 VDD.t475 VDD.t473 13.3338
R1947 VDD.t455 VDD.t475 13.3338
R1948 VDD.t307 VDD.t455 13.3338
R1949 VDD.t479 VDD.t307 13.3338
R1950 VDD.t481 VDD.t479 13.3338
R1951 VDD.t483 VDD.t481 13.3338
R1952 VDD.t566 VDD.t564 13.3338
R1953 VDD.t572 VDD.t566 13.3338
R1954 VDD.t574 VDD.t572 13.3338
R1955 VDD.t570 VDD.t574 13.3338
R1956 VDD.t568 VDD.t570 13.3338
R1957 VDD.t576 VDD.t568 13.3338
R1958 VDD.t578 VDD.t576 13.3338
R1959 VDD.t71 VDD.t72 13.3338
R1960 VDD.t1 VDD.t71 13.3338
R1961 VDD.t0 VDD.t1 13.3338
R1962 VDD.n279 VDD.t0 13.3338
R1963 VDD.t347 VDD.t343 13.3338
R1964 VDD.t343 VDD.t345 13.3338
R1965 VDD.t345 VDD.t305 13.3338
R1966 VDD.t353 VDD.t303 13.3338
R1967 VDD.t351 VDD.t353 13.3338
R1968 VDD.t357 VDD.t351 13.3338
R1969 VDD.t309 VDD.t299 13.3338
R1970 VDD.t461 VDD.t309 13.3338
R1971 VDD.t513 VDD.t461 13.3338
R1972 VDD.t499 VDD.t203 13.3338
R1973 VDD.t501 VDD.t499 13.3338
R1974 VDD.t301 VDD.t501 13.3338
R1975 VDD.t88 VDD.t82 13.3338
R1976 VDD.t85 VDD.t88 13.3338
R1977 VDD.t58 VDD.t85 13.3338
R1978 VDD.t92 VDD.t90 13.3338
R1979 VDD.t94 VDD.t92 13.3338
R1980 VDD.t96 VDD.t94 13.3338
R1981 VDD.n252 VDD.t73 13.3338
R1982 VDD.t73 VDD.t14 13.3338
R1983 VDD.t14 VDD.t79 13.3338
R1984 VDD.t79 VDD.t78 13.3338
R1985 VDD.t34 VDD.t36 13.3338
R1986 VDD.t38 VDD.t34 13.3338
R1987 VDD.t40 VDD.t38 13.3338
R1988 VDD.t42 VDD.t40 13.3338
R1989 VDD.t44 VDD.t42 13.3338
R1990 VDD.t32 VDD.t44 13.3338
R1991 VDD.t46 VDD.t32 13.3338
R1992 VDD.t154 VDD.t152 13.3338
R1993 VDD.t150 VDD.t154 13.3338
R1994 VDD.t156 VDD.t150 13.3338
R1995 VDD.t60 VDD.t156 13.3338
R1996 VDD.t158 VDD.t60 13.3338
R1997 VDD.t161 VDD.t158 13.3338
R1998 VDD.t163 VDD.t161 13.3338
R1999 VDD.t463 VDD.t457 13.3338
R2000 VDD.t457 VDD.t459 13.3338
R2001 VDD.t459 VDD.t503 13.3338
R2002 VDD.t503 VDD.n241 13.3338
R2003 VDD.n20 VDD.n19 13.26
R2004 VDD.n525 VDD.n489 13.2291
R2005 VDD.n482 VDD.n469 13.2291
R2006 VDD.n547 VDD.n539 12.3348
R2007 VDD.n441 VDD.n439 12.2524
R2008 VDD.n184 VDD.n182 12.2524
R2009 VDD.n503 VDD.n502 11.9744
R2010 VDD.n572 VDD.n571 11.9744
R2011 VDD.n447 VDD.n445 11.8107
R2012 VDD.n193 VDD.n191 11.8107
R2013 VDD.n413 VDD.n412 11.7788
R2014 VDD.n156 VDD.n155 11.7788
R2015 VDD.n409 VDD.n408 11.7396
R2016 VDD.n147 VDD.n146 11.7396
R2017 VDD.n3 VDD.t370 11.724
R2018 VDD.n2 VDD.t506 11.724
R2019 VDD.n8 VDD.t510 11.724
R2020 VDD.n1 VDD.t5 11.724
R2021 VDD.n13 VDD.t106 11.724
R2022 VDD.n0 VDD.t126 11.724
R2023 VDD.n18 VDD.t192 11.724
R2024 VDD.n19 VDD.n18 11.1202
R2025 VDD.n402 VDD.n400 10.5755
R2026 VDD.n135 VDD.n133 10.5755
R2027 VDD.n435 VDD.t55 10.4271
R2028 VDD.n425 VDD.t57 10.4271
R2029 VDD.n168 VDD.t51 10.4271
R2030 VDD.n172 VDD.t53 10.4271
R2031 VDD.n502 VDD.n501 10.1049
R2032 VDD.n571 VDD.n570 10.1049
R2033 VDD.t442 VDD.n346 10.0005
R2034 VDD.t420 VDD.t237 10.0005
R2035 VDD.t205 VDD.t401 10.0005
R2036 VDD.t207 VDD.t415 10.0005
R2037 VDD.t209 VDD.t413 10.0005
R2038 VDD.t211 VDD.t200 10.0005
R2039 VDD.t219 VDD.t198 10.0005
R2040 VDD.t227 VDD.t146 10.0005
R2041 VDD.t229 VDD.t144 10.0005
R2042 VDD.t231 VDD.t142 10.0005
R2043 VDD.t233 VDD.t66 10.0005
R2044 VDD.t235 VDD.t64 10.0005
R2045 VDD.t559 VDD.t239 10.0005
R2046 VDD.n372 VDD.t171 10.0005
R2047 VDD.n118 VDD.t391 10.0005
R2048 VDD.t453 VDD.t555 10.0005
R2049 VDD.t317 VDD.t494 10.0005
R2050 VDD.t319 VDD.t492 10.0005
R2051 VDD.t321 VDD.t131 10.0005
R2052 VDD.t327 VDD.t129 10.0005
R2053 VDD.t329 VDD.t140 10.0005
R2054 VDD.t397 VDD.t335 10.0005
R2055 VDD.t395 VDD.t337 10.0005
R2056 VDD.t393 VDD.t325 10.0005
R2057 VDD.t409 VDD.t339 10.0005
R2058 VDD.t407 VDD.t341 10.0005
R2059 VDD.t539 VDD.t76 10.0005
R2060 VDD.n74 VDD.t485 10.0005
R2061 VDD.n438 VDD.n437 9.82224
R2062 VDD.n181 VDD.n180 9.82224
R2063 VDD.n342 VDD.n339 9.31191
R2064 VDD.n77 VDD.n69 9.31191
R2065 VDD.n246 VDD.n236 9.31191
R2066 VDD.n473 VDD.n468 8.84398
R2067 VDD.n581 VDD.n580 8.5845
R2068 VDD.n481 VDD.n473 8.00988
R2069 VDD.n502 VDD.n500 7.43528
R2070 VDD.n571 VDD.n569 7.43528
R2071 VDD.n445 VDD.n379 7.27876
R2072 VDD.n435 VDD.n427 7.27876
R2073 VDD.n426 VDD.n425 7.27876
R2074 VDD.n409 VDD.n383 7.27876
R2075 VDD.n147 VDD.n126 7.27876
R2076 VDD.n169 VDD.n168 7.27876
R2077 VDD.n172 VDD.n170 7.27876
R2078 VDD.n191 VDD.n125 7.27876
R2079 VDD.n436 VDD.n435 7.13872
R2080 VDD.n179 VDD.n172 7.13872
R2081 VDD.n526 VDD.n483 6.88746
R2082 VDD.n536 VDD.n535 6.88746
R2083 VDD.n549 VDD.n548 6.88746
R2084 VDD.n342 VDD.n341 6.79358
R2085 VDD.n72 VDD.n69 6.79358
R2086 VDD.n239 VDD.n236 6.79358
R2087 VDD.n354 VDD.t273 6.66717
R2088 VDD.t167 VDD.t215 6.66717
R2089 VDD.t243 VDD.t133 6.66717
R2090 VDD.n355 VDD.t21 6.66717
R2091 VDD.t23 VDD.n355 6.66717
R2092 VDD.t25 VDD.n325 6.66717
R2093 VDD.n325 VDD.t26 6.66717
R2094 VDD.n361 VDD.t27 6.66717
R2095 VDD.n361 VDD.t29 6.66717
R2096 VDD.t400 VDD.t271 6.66717
R2097 VDD.t292 VDD.t223 6.66717
R2098 VDD.n314 VDD.t277 6.66717
R2099 VDD.t547 VDD.n105 6.66717
R2100 VDD.t296 VDD.t331 6.66717
R2101 VDD.t515 VDD.t417 6.66717
R2102 VDD.n97 VDD.t115 6.66717
R2103 VDD.t117 VDD.n97 6.66717
R2104 VDD.t119 VDD.n96 6.66717
R2105 VDD.n96 VDD.t120 6.66717
R2106 VDD.n87 VDD.t123 6.66717
R2107 VDD.t121 VDD.n87 6.66717
R2108 VDD.t444 VDD.t553 6.66717
R2109 VDD.t315 VDD.t491 6.66717
R2110 VDD.n88 VDD.t521 6.66717
R2111 VDD.t305 VDD.n278 6.66717
R2112 VDD.n278 VDD.t303 6.66717
R2113 VDD.n269 VDD.t12 6.66717
R2114 VDD.t10 VDD.n269 6.66717
R2115 VDD.n256 VDD.t561 6.66717
R2116 VDD.t16 VDD.n256 6.66717
R2117 VDD.n258 VDD.t58 6.66717
R2118 VDD.n258 VDD.t90 6.66717
R2119 VDD.n302 VDD.n299 6.3005
R2120 VDD.n373 VDD.t430 6.3005
R2121 VDD.n374 VDD.n373 6.3005
R2122 VDD.n372 VDD.n303 6.3005
R2123 VDD.n303 VDD.n301 6.3005
R2124 VDD.n371 VDD.n370 6.3005
R2125 VDD.n370 VDD.n369 6.3005
R2126 VDD.n307 VDD.n306 6.3005
R2127 VDD.n368 VDD.n307 6.3005
R2128 VDD.n366 VDD.n365 6.3005
R2129 VDD.n367 VDD.n366 6.3005
R2130 VDD.n314 VDD.n312 6.3005
R2131 VDD.n312 VDD.n311 6.3005
R2132 VDD.n315 VDD.t293 6.3005
R2133 VDD.n317 VDD.n315 6.3005
R2134 VDD.t241 VDD.n360 6.3005
R2135 VDD.n360 VDD.n359 6.3005
R2136 VDD.n325 VDD.n316 6.3005
R2137 VDD.n358 VDD.n316 6.3005
R2138 VDD.n356 VDD.t259 6.3005
R2139 VDD.n357 VDD.n356 6.3005
R2140 VDD.t166 VDD.n324 6.3005
R2141 VDD.n324 VDD.n323 6.3005
R2142 VDD.n354 VDD.n353 6.3005
R2143 VDD.n353 VDD.n352 6.3005
R2144 VDD.n333 VDD.n326 6.3005
R2145 VDD.n351 VDD.n326 6.3005
R2146 VDD.n349 VDD.n348 6.3005
R2147 VDD.n350 VDD.n349 6.3005
R2148 VDD.n347 VDD.n332 6.3005
R2149 VDD.n332 VDD.n331 6.3005
R2150 VDD.n346 VDD.n345 6.3005
R2151 VDD.n345 VDD.n344 6.3005
R2152 VDD.t187 VDD.n337 6.3005
R2153 VDD.n343 VDD.n337 6.3005
R2154 VDD.t281 VDD.n71 6.3005
R2155 VDD.n71 VDD.n70 6.3005
R2156 VDD.n75 VDD.n74 6.3005
R2157 VDD.n76 VDD.n75 6.3005
R2158 VDD.n67 VDD.n66 6.3005
R2159 VDD.n68 VDD.n67 6.3005
R2160 VDD.n82 VDD.n81 6.3005
R2161 VDD.n81 VDD.n80 6.3005
R2162 VDD.n83 VDD.n64 6.3005
R2163 VDD.n64 VDD.n63 6.3005
R2164 VDD.n89 VDD.n88 6.3005
R2165 VDD.n90 VDD.n89 6.3005
R2166 VDD.t449 VDD.n60 6.3005
R2167 VDD.n61 VDD.n60 6.3005
R2168 VDD.t541 VDD.n95 6.3005
R2169 VDD.n95 VDD.n94 6.3005
R2170 VDD.n96 VDD.n59 6.3005
R2171 VDD.n59 VDD.n58 6.3005
R2172 VDD.n98 VDD.t527 6.3005
R2173 VDD.n99 VDD.n98 6.3005
R2174 VDD.t295 VDD.n55 6.3005
R2175 VDD.n56 VDD.n55 6.3005
R2176 VDD.n105 VDD.n104 6.3005
R2177 VDD.n104 VDD.n103 6.3005
R2178 VDD.n53 VDD.n52 6.3005
R2179 VDD.n52 VDD.n51 6.3005
R2180 VDD.n111 VDD.n110 6.3005
R2181 VDD.n112 VDD.n111 6.3005
R2182 VDD.n109 VDD.n48 6.3005
R2183 VDD.n49 VDD.n48 6.3005
R2184 VDD.n118 VDD.n117 6.3005
R2185 VDD.n117 VDD.n116 6.3005
R2186 VDD.t381 VDD.n47 6.3005
R2187 VDD.n47 VDD.n46 6.3005
R2188 VDD.n121 VDD.n120 6.3005
R2189 VDD.n296 VDD.n295 6.3005
R2190 VDD.n293 VDD.n216 6.3005
R2191 VDD.n216 VDD.n215 6.3005
R2192 VDD.n292 VDD.n291 6.3005
R2193 VDD.n291 VDD.n290 6.3005
R2194 VDD.n283 VDD.n217 6.3005
R2195 VDD.n218 VDD.n217 6.3005
R2196 VDD.n285 VDD.n284 6.3005
R2197 VDD.n286 VDD.n285 6.3005
R2198 VDD.n279 VDD.n221 6.3005
R2199 VDD.n221 VDD.n220 6.3005
R2200 VDD.n278 VDD.n277 6.3005
R2201 VDD.n277 VDD.n276 6.3005
R2202 VDD.n268 VDD.n223 6.3005
R2203 VDD.n224 VDD.n223 6.3005
R2204 VDD.n271 VDD.n270 6.3005
R2205 VDD.n272 VDD.n271 6.3005
R2206 VDD.n267 VDD.n227 6.3005
R2207 VDD.n227 VDD.n226 6.3005
R2208 VDD.n266 VDD.n265 6.3005
R2209 VDD.n265 VDD.n264 6.3005
R2210 VDD.n257 VDD.n228 6.3005
R2211 VDD.n229 VDD.n228 6.3005
R2212 VDD.n259 VDD.n258 6.3005
R2213 VDD.n260 VDD.n259 6.3005
R2214 VDD.n252 VDD.n232 6.3005
R2215 VDD.n232 VDD.n231 6.3005
R2216 VDD.n251 VDD.n250 6.3005
R2217 VDD.n250 VDD.n249 6.3005
R2218 VDD.n242 VDD.n234 6.3005
R2219 VDD.n235 VDD.n234 6.3005
R2220 VDD.n244 VDD.n243 6.3005
R2221 VDD.n245 VDD.n244 6.3005
R2222 VDD.n241 VDD.n238 6.3005
R2223 VDD.n238 VDD.n237 6.3005
R2224 VDD.n466 VDD.n465 5.66103
R2225 VDD.n212 VDD.n211 5.66103
R2226 VDD.n467 VDD.n20 5.6305
R2227 VDD.n535 VDD.n534 5.54261
R2228 VDD.n460 VDD.n458 5.51014
R2229 VDD.n382 VDD.n380 5.51014
R2230 VDD.n431 VDD.n429 5.51014
R2231 VDD.n391 VDD.n389 5.51014
R2232 VDD.n386 VDD.n384 5.51014
R2233 VDD.n396 VDD.n394 5.51014
R2234 VDD.n130 VDD.n128 5.51014
R2235 VDD.n152 VDD.n150 5.51014
R2236 VDD.n145 VDD.n143 5.51014
R2237 VDD.n175 VDD.n173 5.51014
R2238 VDD.n189 VDD.n187 5.51014
R2239 VDD.n208 VDD.n206 5.51014
R2240 VDD.n492 VDD.n490 5.51014
R2241 VDD.n496 VDD.n494 5.51014
R2242 VDD.n509 VDD.n507 5.51014
R2243 VDD.n487 VDD.n485 5.51014
R2244 VDD.n519 VDD.n517 5.51014
R2245 VDD.n472 VDD.n470 5.51014
R2246 VDD.n476 VDD.n474 5.51014
R2247 VDD.n542 VDD.n540 5.51014
R2248 VDD.n557 VDD.n555 5.51014
R2249 VDD.n565 VDD.n563 5.51014
R2250 VDD.n575 VDD.n573 5.51014
R2251 VDD.n400 VDD.n399 5.4159
R2252 VDD.n133 VDD.n127 5.4159
R2253 VDD.n460 VDD.n459 5.32067
R2254 VDD.n464 VDD.n461 5.32067
R2255 VDD.n463 VDD.n462 5.32067
R2256 VDD.n382 VDD.n381 5.32067
R2257 VDD.n443 VDD.n442 5.32067
R2258 VDD.n441 VDD.n440 5.32067
R2259 VDD.n453 VDD.n452 5.32067
R2260 VDD.n451 VDD.n450 5.32067
R2261 VDD.n449 VDD.n448 5.32067
R2262 VDD.n447 VDD.n446 5.32067
R2263 VDD.n431 VDD.n430 5.32067
R2264 VDD.n433 VDD.n432 5.32067
R2265 VDD.n436 VDD.n434 5.32067
R2266 VDD.n423 VDD.n416 5.32067
R2267 VDD.n422 VDD.n421 5.32067
R2268 VDD.n420 VDD.n419 5.32067
R2269 VDD.n418 VDD.n417 5.32067
R2270 VDD.n391 VDD.n390 5.32067
R2271 VDD.n407 VDD.n406 5.32067
R2272 VDD.n405 VDD.n404 5.32067
R2273 VDD.n386 VDD.n385 5.32067
R2274 VDD.n388 VDD.n387 5.32067
R2275 VDD.n411 VDD.n410 5.32067
R2276 VDD.n396 VDD.n395 5.32067
R2277 VDD.n398 VDD.n397 5.32067
R2278 VDD.n132 VDD.n131 5.32067
R2279 VDD.n130 VDD.n129 5.32067
R2280 VDD.n149 VDD.n148 5.32067
R2281 VDD.n154 VDD.n153 5.32067
R2282 VDD.n152 VDD.n151 5.32067
R2283 VDD.n140 VDD.n139 5.32067
R2284 VDD.n142 VDD.n141 5.32067
R2285 VDD.n145 VDD.n144 5.32067
R2286 VDD.n160 VDD.n159 5.32067
R2287 VDD.n162 VDD.n161 5.32067
R2288 VDD.n164 VDD.n163 5.32067
R2289 VDD.n166 VDD.n165 5.32067
R2290 VDD.n179 VDD.n178 5.32067
R2291 VDD.n177 VDD.n176 5.32067
R2292 VDD.n175 VDD.n174 5.32067
R2293 VDD.n193 VDD.n192 5.32067
R2294 VDD.n195 VDD.n194 5.32067
R2295 VDD.n197 VDD.n196 5.32067
R2296 VDD.n199 VDD.n198 5.32067
R2297 VDD.n184 VDD.n183 5.32067
R2298 VDD.n186 VDD.n185 5.32067
R2299 VDD.n189 VDD.n188 5.32067
R2300 VDD.n205 VDD.n204 5.32067
R2301 VDD.n210 VDD.n209 5.32067
R2302 VDD.n208 VDD.n207 5.32067
R2303 VDD.n492 VDD.n491 5.32067
R2304 VDD.n500 VDD.n499 5.32067
R2305 VDD.n498 VDD.n497 5.32067
R2306 VDD.n496 VDD.n495 5.32067
R2307 VDD.n506 VDD.n505 5.32067
R2308 VDD.n511 VDD.n510 5.32067
R2309 VDD.n509 VDD.n508 5.32067
R2310 VDD.n487 VDD.n486 5.32067
R2311 VDD.n528 VDD.n527 5.32067
R2312 VDD.n530 VDD.n529 5.32067
R2313 VDD.n532 VDD.n531 5.32067
R2314 VDD.n534 VDD.n533 5.32067
R2315 VDD.n523 VDD.n522 5.32067
R2316 VDD.n521 VDD.n520 5.32067
R2317 VDD.n519 VDD.n518 5.32067
R2318 VDD.n472 VDD.n471 5.32067
R2319 VDD.n480 VDD.n479 5.32067
R2320 VDD.n478 VDD.n477 5.32067
R2321 VDD.n476 VDD.n475 5.32067
R2322 VDD.n546 VDD.n545 5.32067
R2323 VDD.n544 VDD.n543 5.32067
R2324 VDD.n542 VDD.n541 5.32067
R2325 VDD.n554 VDD.n553 5.32067
R2326 VDD.n559 VDD.n558 5.32067
R2327 VDD.n557 VDD.n556 5.32067
R2328 VDD.n569 VDD.n568 5.32067
R2329 VDD.n567 VDD.n566 5.32067
R2330 VDD.n565 VDD.n564 5.32067
R2331 VDD.n575 VDD.n574 5.32067
R2332 VDD.n577 VDD.n576 5.28208
R2333 VDD.n526 VDD.n525 5.08746
R2334 VDD.n548 VDD.n482 5.08746
R2335 VDD.n488 VDD.n487 5.02155
R2336 VDD.n528 VDD.n526 4.68997
R2337 VDD.n411 VDD.n409 4.59524
R2338 VDD.n149 VDD.n147 4.59524
R2339 VDD.n473 VDD.n472 4.54787
R2340 VDD.n445 VDD.n444 4.5005
R2341 VDD.n437 VDD.n436 4.5005
R2342 VDD.n424 VDD.n423 4.5005
R2343 VDD.n167 VDD.n166 4.5005
R2344 VDD.n180 VDD.n179 4.5005
R2345 VDD.n191 VDD.n190 4.5005
R2346 VDD.n525 VDD.n524 4.5005
R2347 VDD.n548 VDD.n547 4.5005
R2348 VDD.n482 VDD.n481 4.5005
R2349 VDD.n578 VDD.n577 4.4605
R2350 VDD.n403 VDD.n402 4.31103
R2351 VDD.n138 VDD.n135 4.31103
R2352 VDD.n456 VDD.n454 4.12155
R2353 VDD.n202 VDD.n200 4.12155
R2354 VDD.t422 VDD.n354 3.33383
R2355 VDD.t237 VDD.t422 3.33383
R2356 VDD.t415 VDD.t205 3.33383
R2357 VDD.t413 VDD.t207 3.33383
R2358 VDD.t200 VDD.t209 3.33383
R2359 VDD.t198 VDD.t211 3.33383
R2360 VDD.t146 VDD.t229 3.33383
R2361 VDD.t144 VDD.t231 3.33383
R2362 VDD.t142 VDD.t233 3.33383
R2363 VDD.t66 VDD.t235 3.33383
R2364 VDD.t239 VDD.t557 3.33383
R2365 VDD.t557 VDD.n314 3.33383
R2366 VDD.n105 VDD.t489 3.33383
R2367 VDD.t555 VDD.t489 3.33383
R2368 VDD.t492 VDD.t317 3.33383
R2369 VDD.t131 VDD.t319 3.33383
R2370 VDD.t129 VDD.t321 3.33383
R2371 VDD.t140 VDD.t327 3.33383
R2372 VDD.t337 VDD.t397 3.33383
R2373 VDD.t325 VDD.t395 3.33383
R2374 VDD.t339 VDD.t393 3.33383
R2375 VDD.t341 VDD.t409 3.33383
R2376 VDD.t74 VDD.t539 3.33383
R2377 VDD.n88 VDD.t74 3.33383
R2378 VDD.n538 VDD.n536 3.26892
R2379 VDD.n27 VDD.n23 3.1805
R2380 VDD.n42 VDD.n38 3.0962
R2381 VDD.n577 VDD.n467 2.7705
R2382 VDD.n580 VDD.n27 2.5955
R2383 VDD.n425 VDD.n424 2.54398
R2384 VDD.n168 VDD.n167 2.54398
R2385 VDD.n26 VDD.n24 2.28717
R2386 VDD.n41 VDD.n39 2.26494
R2387 VDD.n42 VDD.n41 2.20416
R2388 VDD.n427 VDD.n426 2.17945
R2389 VDD.n170 VDD.n169 2.17945
R2390 VDD.n578 VDD.n212 2.1305
R2391 VDD.n467 VDD.n466 2.1005
R2392 VDD.n535 VDD.n488 1.95702
R2393 VDD.n579 VDD.n578 1.8805
R2394 VDD.n536 VDD.n483 1.8005
R2395 VDD.n579 VDD.n43 1.69099
R2396 VDD.n552 VDD.n551 1.61103
R2397 VDD.n576 VDD.n572 1.51629
R2398 VDD.n551 VDD.n549 1.42155
R2399 VDD.n504 VDD.n503 1.42155
R2400 VDD.n336 VDD.n335 1.26366
R2401 VDD.n335 VDD.n313 1.26366
R2402 VDD.n362 VDD.n313 1.26366
R2403 VDD.n363 VDD.n362 1.26366
R2404 VDD.n363 VDD.n305 1.26366
R2405 VDD.n305 VDD.n298 1.26366
R2406 VDD.n108 VDD.n44 1.26366
R2407 VDD.n108 VDD.n107 1.26366
R2408 VDD.n107 VDD.n54 1.26366
R2409 VDD.n86 VDD.n54 1.26366
R2410 VDD.n86 VDD.n85 1.26366
R2411 VDD.n85 VDD.n65 1.26366
R2412 VDD.n282 VDD.n281 1.26366
R2413 VDD.n281 VDD.n222 1.26366
R2414 VDD.n255 VDD.n222 1.26366
R2415 VDD.n255 VDD.n254 1.26366
R2416 VDD.n254 VDD.n233 1.26366
R2417 VDD.n562 VDD.n561 1.23208
R2418 VDD.n282 VDD.n213 1.21103
R2419 VDD.n515 VDD.n513 1.13734
R2420 VDD.n539 VDD.n538 1.08997
R2421 VDD.n414 VDD.n413 1.04261
R2422 VDD.n157 VDD.n156 1.04261
R2423 VDD.n29 VDD.n28 1.03676
R2424 VDD.n344 VDD.n343 1.0005
R2425 VDD.n344 VDD.n331 1.0005
R2426 VDD.n350 VDD.n331 1.0005
R2427 VDD.n351 VDD.n350 1.0005
R2428 VDD.n352 VDD.n351 1.0005
R2429 VDD.n352 VDD.n323 1.0005
R2430 VDD.n357 VDD.n323 1.0005
R2431 VDD.n358 VDD.n357 1.0005
R2432 VDD.n359 VDD.n358 1.0005
R2433 VDD.n359 VDD.n317 1.0005
R2434 VDD.n317 VDD.n311 1.0005
R2435 VDD.n367 VDD.n311 1.0005
R2436 VDD.n368 VDD.n367 1.0005
R2437 VDD.n369 VDD.n368 1.0005
R2438 VDD.n369 VDD.n301 1.0005
R2439 VDD.n374 VDD.n301 1.0005
R2440 VDD.n374 VDD.n299 1.0005
R2441 VDD.n121 VDD.n46 1.0005
R2442 VDD.n116 VDD.n46 1.0005
R2443 VDD.n116 VDD.n49 1.0005
R2444 VDD.n112 VDD.n49 1.0005
R2445 VDD.n112 VDD.n51 1.0005
R2446 VDD.n103 VDD.n51 1.0005
R2447 VDD.n103 VDD.n56 1.0005
R2448 VDD.n99 VDD.n56 1.0005
R2449 VDD.n99 VDD.n58 1.0005
R2450 VDD.n94 VDD.n58 1.0005
R2451 VDD.n94 VDD.n61 1.0005
R2452 VDD.n90 VDD.n61 1.0005
R2453 VDD.n90 VDD.n63 1.0005
R2454 VDD.n80 VDD.n63 1.0005
R2455 VDD.n80 VDD.n68 1.0005
R2456 VDD.n76 VDD.n68 1.0005
R2457 VDD.n76 VDD.n70 1.0005
R2458 VDD.n296 VDD.n215 1.0005
R2459 VDD.n290 VDD.n215 1.0005
R2460 VDD.n290 VDD.n218 1.0005
R2461 VDD.n286 VDD.n218 1.0005
R2462 VDD.n286 VDD.n220 1.0005
R2463 VDD.n276 VDD.n220 1.0005
R2464 VDD.n276 VDD.n224 1.0005
R2465 VDD.n272 VDD.n224 1.0005
R2466 VDD.n272 VDD.n226 1.0005
R2467 VDD.n264 VDD.n226 1.0005
R2468 VDD.n264 VDD.n229 1.0005
R2469 VDD.n260 VDD.n229 1.0005
R2470 VDD.n260 VDD.n231 1.0005
R2471 VDD.n249 VDD.n231 1.0005
R2472 VDD.n249 VDD.n235 1.0005
R2473 VDD.n245 VDD.n235 1.0005
R2474 VDD.n245 VDD.n237 1.0005
R2475 VDD.n439 VDD.n438 0.947868
R2476 VDD.n182 VDD.n181 0.947868
R2477 VDD.n516 VDD.n515 0.947868
R2478 VDD.n43 VDD.n30 0.884153
R2479 VDD.n457 VDD.n456 0.876816
R2480 VDD.n203 VDD.n202 0.876816
R2481 VDD.n426 VDD.n414 0.853132
R2482 VDD.n169 VDD.n157 0.853132
R2483 VDD.n4 VDD.n3 0.8005
R2484 VDD.n7 VDD.n2 0.8005
R2485 VDD.n9 VDD.n8 0.8005
R2486 VDD.n12 VDD.n1 0.8005
R2487 VDD.n14 VDD.n13 0.8005
R2488 VDD.n17 VDD.n0 0.8005
R2489 VDD.n439 VDD.n379 0.758395
R2490 VDD.n182 VDD.n125 0.758395
R2491 VDD.n43 VDD.n42 0.745997
R2492 VDD.n23 VDD.n22 0.7005
R2493 VDD.n454 VDD.n378 0.592605
R2494 VDD.n200 VDD.n124 0.592605
R2495 VDD.n539 VDD.n468 0.568921
R2496 VDD.n393 VDD.n383 0.521553
R2497 VDD.n379 VDD.n378 0.521553
R2498 VDD.n125 VDD.n124 0.521553
R2499 VDD.n137 VDD.n126 0.521553
R2500 VDD.n27 VDD.n26 0.507167
R2501 VDD.n343 VDD.n342 0.481712
R2502 VDD.n70 VDD.n69 0.481712
R2503 VDD.n237 VDD.n236 0.481712
R2504 VDD.n516 VDD.n483 0.474184
R2505 VDD.n34 VDD.n33 0.451962
R2506 VDD.n339 VDD.n338 0.444944
R2507 VDD.n338 VDD.n330 0.444944
R2508 VDD.n330 VDD.n329 0.444944
R2509 VDD.n329 VDD.n328 0.444944
R2510 VDD.n328 VDD.n327 0.444944
R2511 VDD.n327 VDD.n322 0.444944
R2512 VDD.n322 VDD.n321 0.444944
R2513 VDD.n321 VDD.n320 0.444944
R2514 VDD.n320 VDD.n319 0.444944
R2515 VDD.n319 VDD.n318 0.444944
R2516 VDD.n318 VDD.n310 0.444944
R2517 VDD.n310 VDD.n309 0.444944
R2518 VDD.n309 VDD.n308 0.444944
R2519 VDD.n308 VDD.n300 0.444944
R2520 VDD.n375 VDD.n300 0.444944
R2521 VDD.n115 VDD.n45 0.444944
R2522 VDD.n115 VDD.n114 0.444944
R2523 VDD.n114 VDD.n113 0.444944
R2524 VDD.n113 VDD.n50 0.444944
R2525 VDD.n102 VDD.n50 0.444944
R2526 VDD.n102 VDD.n101 0.444944
R2527 VDD.n101 VDD.n100 0.444944
R2528 VDD.n100 VDD.n57 0.444944
R2529 VDD.n93 VDD.n57 0.444944
R2530 VDD.n93 VDD.n92 0.444944
R2531 VDD.n92 VDD.n91 0.444944
R2532 VDD.n91 VDD.n62 0.444944
R2533 VDD.n79 VDD.n62 0.444944
R2534 VDD.n79 VDD.n78 0.444944
R2535 VDD.n78 VDD.n77 0.444944
R2536 VDD.n289 VDD.n214 0.444944
R2537 VDD.n289 VDD.n288 0.444944
R2538 VDD.n288 VDD.n287 0.444944
R2539 VDD.n287 VDD.n219 0.444944
R2540 VDD.n275 VDD.n219 0.444944
R2541 VDD.n275 VDD.n274 0.444944
R2542 VDD.n274 VDD.n273 0.444944
R2543 VDD.n273 VDD.n225 0.444944
R2544 VDD.n263 VDD.n225 0.444944
R2545 VDD.n263 VDD.n262 0.444944
R2546 VDD.n262 VDD.n261 0.444944
R2547 VDD.n261 VDD.n230 0.444944
R2548 VDD.n248 VDD.n230 0.444944
R2549 VDD.n248 VDD.n247 0.444944
R2550 VDD.n247 VDD.n246 0.444944
R2551 VDD.n549 VDD.n468 0.379447
R2552 VDD.n32 VDD.n31 0.356056
R2553 VDD.n33 VDD.n32 0.356056
R2554 VDD.n30 VDD.n29 0.337342
R2555 VDD.n376 VDD.n375 0.311611
R2556 VDD.n122 VDD.n45 0.311611
R2557 VDD.n26 VDD.n25 0.238278
R2558 VDD.n458 VDD.t431 0.228
R2559 VDD.n458 VDD.t439 0.228
R2560 VDD.n459 VDD.t435 0.228
R2561 VDD.n459 VDD.t433 0.228
R2562 VDD.n461 VDD.t427 0.228
R2563 VDD.n461 VDD.t437 0.228
R2564 VDD.n462 VDD.t425 0.228
R2565 VDD.n462 VDD.t429 0.228
R2566 VDD.n455 VDD.t178 0.228
R2567 VDD.n455 VDD.t172 0.228
R2568 VDD.n380 VDD.t234 0.228
R2569 VDD.n380 VDD.t236 0.228
R2570 VDD.n381 VDD.t230 0.228
R2571 VDD.n381 VDD.t232 0.228
R2572 VDD.n442 VDD.t226 0.228
R2573 VDD.n442 VDD.t228 0.228
R2574 VDD.n440 VDD.t224 0.228
R2575 VDD.n440 VDD.t214 0.228
R2576 VDD.n452 VDD.t560 0.228
R2577 VDD.n452 VDD.t558 0.228
R2578 VDD.n450 VDD.t65 0.228
R2579 VDD.n450 VDD.t63 0.228
R2580 VDD.n448 VDD.t143 0.228
R2581 VDD.n448 VDD.t67 0.228
R2582 VDD.n446 VDD.t147 0.228
R2583 VDD.n446 VDD.t145 0.228
R2584 VDD.n377 VDD.t240 0.228
R2585 VDD.n377 VDD.t278 0.228
R2586 VDD.n428 VDD.t28 0.228
R2587 VDD.n428 VDD.t30 0.228
R2588 VDD.n429 VDD.t276 0.228
R2589 VDD.n429 VDD.t272 0.228
R2590 VDD.n430 VDD.t270 0.228
R2591 VDD.n430 VDD.t248 0.228
R2592 VDD.n432 VDD.t268 0.228
R2593 VDD.n432 VDD.t269 0.228
R2594 VDD.n434 VDD.t246 0.228
R2595 VDD.n434 VDD.t242 0.228
R2596 VDD.n415 VDD.t22 0.228
R2597 VDD.n415 VDD.t24 0.228
R2598 VDD.n416 VDD.t260 0.228
R2599 VDD.n416 VDD.t250 0.228
R2600 VDD.n421 VDD.t256 0.228
R2601 VDD.n421 VDD.t258 0.228
R2602 VDD.n419 VDD.t254 0.228
R2603 VDD.n419 VDD.t255 0.228
R2604 VDD.n417 VDD.t244 0.228
R2605 VDD.n417 VDD.t252 0.228
R2606 VDD.n389 VDD.t201 0.228
R2607 VDD.n389 VDD.t199 0.228
R2608 VDD.n390 VDD.t416 0.228
R2609 VDD.n390 VDD.t414 0.228
R2610 VDD.n406 VDD.t404 0.228
R2611 VDD.n406 VDD.t402 0.228
R2612 VDD.n404 VDD.t423 0.228
R2613 VDD.n404 VDD.t421 0.228
R2614 VDD.n384 VDD.t218 0.228
R2615 VDD.n384 VDD.t216 0.228
R2616 VDD.n385 VDD.t220 0.228
R2617 VDD.n385 VDD.t222 0.228
R2618 VDD.n387 VDD.t210 0.228
R2619 VDD.n387 VDD.t212 0.228
R2620 VDD.n410 VDD.t206 0.228
R2621 VDD.n410 VDD.t208 0.228
R2622 VDD.n392 VDD.t274 0.228
R2623 VDD.n392 VDD.t238 0.228
R2624 VDD.n401 VDD.t443 0.228
R2625 VDD.n401 VDD.t441 0.228
R2626 VDD.n394 VDD.t176 0.228
R2627 VDD.n394 VDD.t174 0.228
R2628 VDD.n395 VDD.t182 0.228
R2629 VDD.n395 VDD.t180 0.228
R2630 VDD.n397 VDD.t186 0.228
R2631 VDD.n397 VDD.t184 0.228
R2632 VDD.n399 VDD.t190 0.228
R2633 VDD.n399 VDD.t188 0.228
R2634 VDD.n127 VDD.t282 0.228
R2635 VDD.n127 VDD.t280 0.228
R2636 VDD.n131 VDD.t286 0.228
R2637 VDD.n131 VDD.t284 0.228
R2638 VDD.n129 VDD.t110 0.228
R2639 VDD.n129 VDD.t288 0.228
R2640 VDD.n128 VDD.t114 0.228
R2641 VDD.n128 VDD.t112 0.228
R2642 VDD.n134 VDD.t488 0.228
R2643 VDD.n134 VDD.t486 0.228
R2644 VDD.n148 VDD.t340 0.228
R2645 VDD.n148 VDD.t342 0.228
R2646 VDD.n153 VDD.t338 0.228
R2647 VDD.n153 VDD.t326 0.228
R2648 VDD.n151 VDD.t334 0.228
R2649 VDD.n151 VDD.t336 0.228
R2650 VDD.n150 VDD.t316 0.228
R2651 VDD.n150 VDD.t312 0.228
R2652 VDD.n139 VDD.t77 0.228
R2653 VDD.n139 VDD.t75 0.228
R2654 VDD.n141 VDD.t408 0.228
R2655 VDD.n141 VDD.t406 0.228
R2656 VDD.n144 VDD.t394 0.228
R2657 VDD.n144 VDD.t410 0.228
R2658 VDD.n143 VDD.t398 0.228
R2659 VDD.n143 VDD.t396 0.228
R2660 VDD.n136 VDD.t540 0.228
R2661 VDD.n136 VDD.t522 0.228
R2662 VDD.n159 VDD.t552 0.228
R2663 VDD.n159 VDD.t554 0.228
R2664 VDD.n161 VDD.t546 0.228
R2665 VDD.n161 VDD.t550 0.228
R2666 VDD.n163 VDD.t544 0.228
R2667 VDD.n163 VDD.t545 0.228
R2668 VDD.n158 VDD.t124 0.228
R2669 VDD.n158 VDD.t122 0.228
R2670 VDD.n165 VDD.t538 0.228
R2671 VDD.n165 VDD.t542 0.228
R2672 VDD.n171 VDD.t116 0.228
R2673 VDD.n171 VDD.t118 0.228
R2674 VDD.n178 VDD.t528 0.228
R2675 VDD.n178 VDD.t530 0.228
R2676 VDD.n176 VDD.t523 0.228
R2677 VDD.n176 VDD.t526 0.228
R2678 VDD.n174 VDD.t520 0.228
R2679 VDD.n174 VDD.t524 0.228
R2680 VDD.n173 VDD.t516 0.228
R2681 VDD.n173 VDD.t518 0.228
R2682 VDD.n192 VDD.t130 0.228
R2683 VDD.n192 VDD.t141 0.228
R2684 VDD.n194 VDD.t493 0.228
R2685 VDD.n194 VDD.t132 0.228
R2686 VDD.n196 VDD.t452 0.228
R2687 VDD.n196 VDD.t495 0.228
R2688 VDD.n198 VDD.t490 0.228
R2689 VDD.n198 VDD.t454 0.228
R2690 VDD.n183 VDD.t314 0.228
R2691 VDD.n183 VDD.t332 0.228
R2692 VDD.n185 VDD.t330 0.228
R2693 VDD.n185 VDD.t324 0.228
R2694 VDD.n188 VDD.t322 0.228
R2695 VDD.n188 VDD.t328 0.228
R2696 VDD.n187 VDD.t318 0.228
R2697 VDD.n187 VDD.t320 0.228
R2698 VDD.n123 VDD.t548 0.228
R2699 VDD.n123 VDD.t556 0.228
R2700 VDD.n201 VDD.t392 0.228
R2701 VDD.n201 VDD.t390 0.228
R2702 VDD.n204 VDD.t386 0.228
R2703 VDD.n204 VDD.t384 0.228
R2704 VDD.n209 VDD.t376 0.228
R2705 VDD.n209 VDD.t388 0.228
R2706 VDD.n207 VDD.t380 0.228
R2707 VDD.n207 VDD.t378 0.228
R2708 VDD.n206 VDD.t374 0.228
R2709 VDD.n206 VDD.t382 0.228
R2710 VDD.n491 VDD.t460 0.228
R2711 VDD.n491 VDD.t504 0.228
R2712 VDD.n490 VDD.t464 0.228
R2713 VDD.n490 VDD.t458 0.228
R2714 VDD.n501 VDD.t165 0.228
R2715 VDD.n501 VDD.t61 0.228
R2716 VDD.n499 VDD.t162 0.228
R2717 VDD.n499 VDD.t164 0.228
R2718 VDD.n497 VDD.t160 0.228
R2719 VDD.n497 VDD.t159 0.228
R2720 VDD.n495 VDD.t151 0.228
R2721 VDD.n495 VDD.t157 0.228
R2722 VDD.n494 VDD.t153 0.228
R2723 VDD.n494 VDD.t155 0.228
R2724 VDD.n505 VDD.t33 0.228
R2725 VDD.n505 VDD.t47 0.228
R2726 VDD.n510 VDD.t43 0.228
R2727 VDD.n510 VDD.t45 0.228
R2728 VDD.n508 VDD.t39 0.228
R2729 VDD.n508 VDD.t41 0.228
R2730 VDD.n507 VDD.t37 0.228
R2731 VDD.n507 VDD.t35 0.228
R2732 VDD.n514 VDD.t15 0.228
R2733 VDD.n514 VDD.t294 0.228
R2734 VDD.n489 VDD.t59 0.228
R2735 VDD.n489 VDD.t469 0.228
R2736 VDD.n484 VDD.t562 0.228
R2737 VDD.n484 VDD.t17 0.228
R2738 VDD.n485 VDD.t502 0.228
R2739 VDD.n485 VDD.t302 0.228
R2740 VDD.n486 VDD.t204 0.228
R2741 VDD.n486 VDD.t500 0.228
R2742 VDD.n527 VDD.t95 0.228
R2743 VDD.n527 VDD.t97 0.228
R2744 VDD.n529 VDD.t91 0.228
R2745 VDD.n529 VDD.t93 0.228
R2746 VDD.n531 VDD.t86 0.228
R2747 VDD.n531 VDD.t84 0.228
R2748 VDD.n533 VDD.t87 0.228
R2749 VDD.n533 VDD.t89 0.228
R2750 VDD.n522 VDD.t103 0.228
R2751 VDD.n522 VDD.t104 0.228
R2752 VDD.n520 VDD.t102 0.228
R2753 VDD.n520 VDD.t99 0.228
R2754 VDD.n518 VDD.t100 0.228
R2755 VDD.n518 VDD.t101 0.228
R2756 VDD.n517 VDD.t83 0.228
R2757 VDD.n517 VDD.t98 0.228
R2758 VDD.n537 VDD.t13 0.228
R2759 VDD.n537 VDD.t11 0.228
R2760 VDD.n469 VDD.t306 0.228
R2761 VDD.n469 VDD.t304 0.228
R2762 VDD.n471 VDD.t462 0.228
R2763 VDD.n471 VDD.t514 0.228
R2764 VDD.n470 VDD.t300 0.228
R2765 VDD.n470 VDD.t310 0.228
R2766 VDD.n479 VDD.t363 0.228
R2767 VDD.n479 VDD.t364 0.228
R2768 VDD.n477 VDD.t361 0.228
R2769 VDD.n477 VDD.t362 0.228
R2770 VDD.n475 VDD.t346 0.228
R2771 VDD.n475 VDD.t360 0.228
R2772 VDD.n474 VDD.t349 0.228
R2773 VDD.n474 VDD.t359 0.228
R2774 VDD.n545 VDD.t352 0.228
R2775 VDD.n545 VDD.t358 0.228
R2776 VDD.n543 VDD.t356 0.228
R2777 VDD.n543 VDD.t354 0.228
R2778 VDD.n541 VDD.t350 0.228
R2779 VDD.n541 VDD.t355 0.228
R2780 VDD.n540 VDD.t348 0.228
R2781 VDD.n540 VDD.t344 0.228
R2782 VDD.n550 VDD.t81 0.228
R2783 VDD.n550 VDD.t80 0.228
R2784 VDD.n553 VDD.t577 0.228
R2785 VDD.n553 VDD.t579 0.228
R2786 VDD.n558 VDD.t571 0.228
R2787 VDD.n558 VDD.t569 0.228
R2788 VDD.n556 VDD.t573 0.228
R2789 VDD.n556 VDD.t575 0.228
R2790 VDD.n555 VDD.t565 0.228
R2791 VDD.n555 VDD.t567 0.228
R2792 VDD.n570 VDD.t456 0.228
R2793 VDD.n570 VDD.t308 0.228
R2794 VDD.n568 VDD.t482 0.228
R2795 VDD.n568 VDD.t484 0.228
R2796 VDD.n566 VDD.t478 0.228
R2797 VDD.n566 VDD.t480 0.228
R2798 VDD.n564 VDD.t476 0.228
R2799 VDD.n564 VDD.t477 0.228
R2800 VDD.n563 VDD.t472 0.228
R2801 VDD.n563 VDD.t474 0.228
R2802 VDD.n574 VDD.t149 0.228
R2803 VDD.n574 VDD.t3 0.228
R2804 VDD.n573 VDD.t466 0.228
R2805 VDD.n573 VDD.t20 0.228
R2806 VDD.n41 VDD.n40 0.227751
R2807 VDD.n403 VDD.n393 0.213658
R2808 VDD.n138 VDD.n137 0.213658
R2809 VDD.n466 VDD.n298 0.191026
R2810 VDD.n212 VDD.n44 0.191026
R2811 VDD.n413 VDD.n383 0.189974
R2812 VDD.n465 VDD.n457 0.189974
R2813 VDD.n464 VDD.n463 0.189974
R2814 VDD.n464 VDD.n460 0.189974
R2815 VDD.n449 VDD.n447 0.189974
R2816 VDD.n451 VDD.n449 0.189974
R2817 VDD.n453 VDD.n451 0.189974
R2818 VDD.n443 VDD.n441 0.189974
R2819 VDD.n436 VDD.n433 0.189974
R2820 VDD.n433 VDD.n431 0.189974
R2821 VDD.n420 VDD.n418 0.189974
R2822 VDD.n422 VDD.n420 0.189974
R2823 VDD.n423 VDD.n422 0.189974
R2824 VDD.n388 VDD.n386 0.189974
R2825 VDD.n407 VDD.n405 0.189974
R2826 VDD.n398 VDD.n396 0.189974
R2827 VDD.n211 VDD.n203 0.189974
R2828 VDD.n156 VDD.n126 0.189974
R2829 VDD.n132 VDD.n130 0.189974
R2830 VDD.n142 VDD.n140 0.189974
R2831 VDD.n154 VDD.n152 0.189974
R2832 VDD.n166 VDD.n164 0.189974
R2833 VDD.n164 VDD.n162 0.189974
R2834 VDD.n162 VDD.n160 0.189974
R2835 VDD.n177 VDD.n175 0.189974
R2836 VDD.n179 VDD.n177 0.189974
R2837 VDD.n186 VDD.n184 0.189974
R2838 VDD.n199 VDD.n197 0.189974
R2839 VDD.n197 VDD.n195 0.189974
R2840 VDD.n195 VDD.n193 0.189974
R2841 VDD.n210 VDD.n208 0.189974
R2842 VDD.n210 VDD.n205 0.189974
R2843 VDD.n498 VDD.n496 0.189974
R2844 VDD.n500 VDD.n498 0.189974
R2845 VDD.n511 VDD.n509 0.189974
R2846 VDD.n521 VDD.n519 0.189974
R2847 VDD.n523 VDD.n521 0.189974
R2848 VDD.n524 VDD.n523 0.189974
R2849 VDD.n534 VDD.n532 0.189974
R2850 VDD.n532 VDD.n530 0.189974
R2851 VDD.n530 VDD.n528 0.189974
R2852 VDD.n544 VDD.n542 0.189974
R2853 VDD.n546 VDD.n544 0.189974
R2854 VDD.n547 VDD.n546 0.189974
R2855 VDD.n478 VDD.n476 0.189974
R2856 VDD.n480 VDD.n478 0.189974
R2857 VDD.n481 VDD.n480 0.189974
R2858 VDD.n559 VDD.n557 0.189974
R2859 VDD.n567 VDD.n565 0.189974
R2860 VDD.n569 VDD.n567 0.189974
R2861 VDD.n35 VDD.n34 0.168921
R2862 VDD.n36 VDD.n35 0.168921
R2863 VDD.n37 VDD.n36 0.168921
R2864 VDD.n297 VDD.n214 0.133833
R2865 VDD.n580 VDD.n579 0.1265
R2866 VDD.n408 VDD.n391 0.118921
R2867 VDD.n146 VDD.n145 0.118921
R2868 VDD.n581 VDD.n20 0.1105
R2869 VDD.n4 VDD.n2 0.1005
R2870 VDD.n8 VDD.n7 0.1005
R2871 VDD.n9 VDD.n1 0.1005
R2872 VDD.n13 VDD.n12 0.1005
R2873 VDD.n14 VDD.n0 0.1005
R2874 VDD.n18 VDD.n17 0.1005
R2875 VDD.n23 VDD.n21 0.1005
R2876 VDD.n438 VDD.n427 0.0952368
R2877 VDD.n444 VDD.n443 0.0952368
R2878 VDD.n444 VDD.n382 0.0952368
R2879 VDD.n412 VDD.n411 0.0952368
R2880 VDD.n412 VDD.n388 0.0952368
R2881 VDD.n181 VDD.n170 0.0952368
R2882 VDD.n155 VDD.n154 0.0952368
R2883 VDD.n155 VDD.n149 0.0952368
R2884 VDD.n190 VDD.n189 0.0952368
R2885 VDD.n190 VDD.n186 0.0952368
R2886 VDD.n572 VDD.n562 0.0952368
R2887 VDD.n561 VDD.n552 0.0952368
R2888 VDD.n513 VDD.n504 0.0952368
R2889 VDD.n503 VDD.n493 0.0952368
R2890 VDD.n512 VDD.n511 0.0952368
R2891 VDD.n512 VDD.n506 0.0952368
R2892 VDD.n560 VDD.n559 0.0952368
R2893 VDD.n560 VDD.n554 0.0952368
R2894 VDD.n400 VDD.n398 0.0948023
R2895 VDD.n133 VDD.n132 0.0948023
R2896 VDD.n408 VDD.n407 0.0715526
R2897 VDD.n146 VDD.n142 0.0715526
R2898 VDD.n38 VDD.n37 0.0678684
R2899 VDD.n466 VDD.n376 0.0505
R2900 VDD.n212 VDD.n122 0.0505
R2901 VDD.n577 VDD.n297 0.0505
R2902 VDD.n577 VDD.n213 0.0331316
R2903 VDD VDD.n581 0.0205
R2904 VSS.n1444 VSS.n66 123500
R2905 VSS.n1342 VSS.t470 48139.4
R2906 VSS.n1343 VSS.n1342 47272.7
R2907 VSS.n1444 VSS.n1443 10017.1
R2908 VSS.n1341 VSS.n314 5590
R2909 VSS.n731 VSS.n66 5225.57
R2910 VSS.n1488 VSS.n93 4239.13
R2911 VSS.n1320 VSS.n386 3801.37
R2912 VSS.t316 VSS.t346 3033.33
R2913 VSS.n1375 VSS.n135 2325.9
R2914 VSS.t346 VSS.t313 1733.33
R2915 VSS.n1333 VSS.n319 1618.73
R2916 VSS.n318 VSS.t316 1462.5
R2917 VSS.t313 VSS.t497 1300
R2918 VSS.n352 VSS.n350 1266.62
R2919 VSS.t470 VSS.n1341 996.668
R2920 VSS.t311 VSS.t151 878.379
R2921 VSS.n352 VSS.n313 780
R2922 VSS.n1347 VSS.n309 780
R2923 VSS.n1345 VSS.n1344 780
R2924 VSS.n1347 VSS.n293 715
R2925 VSS.n1353 VSS.n309 651.125
R2926 VSS.n318 VSS.n314 617.5
R2927 VSS.n865 VSS.n864 571.71
R2928 VSS.n1466 VSS.n1465 515.874
R2929 VSS.n1488 VSS.n1487 515.874
R2930 VSS.n1488 VSS.n94 515.874
R2931 VSS.n1507 VSS.n68 515.874
R2932 VSS.n1343 VSS.n313 507
R2933 VSS.t151 VSS.t318 501.932
R2934 VSS.n1371 VSS.n135 465.916
R2935 VSS.n318 VSS.t311 423.505
R2936 VSS.t225 VSS.n1483 392.065
R2937 VSS.n1494 VSS.t188 392.065
R2938 VSS.t318 VSS.t250 376.449
R2939 VSS.t467 VSS.n114 371.43
R2940 VSS.t520 VSS.n1506 371.43
R2941 VSS.t268 VSS.t260 330.159
R2942 VSS.t64 VSS.t38 330.159
R2943 VSS.t32 VSS.n293 330.079
R2944 VSS.n371 VSS.n370 296.139
R2945 VSS.n373 VSS.n372 296.139
R2946 VSS.n376 VSS.n335 296.139
R2947 VSS.n382 VSS.n331 296.139
R2948 VSS.n1325 VSS.n385 296.139
R2949 VSS.n1324 VSS.n1323 296.139
R2950 VSS.n293 VSS.t14 279.298
R2951 VSS.n1344 VSS.n1343 273
R2952 VSS.n110 VSS.t255 268.255
R2953 VSS.n80 VSS.t54 268.255
R2954 VSS.n1472 VSS.t491 247.619
R2955 VSS.n1472 VSS.t555 247.619
R2956 VSS.n1505 VSS.t129 247.619
R2957 VSS.t202 VSS.n1505 247.619
R2958 VSS.n1465 VSS.n1464 237.303
R2959 VSS.n1520 VSS.n68 237.303
R2960 VSS.n1376 VSS.n1374 234.94
R2961 VSS.n1374 VSS.n293 215.362
R2962 VSS.n1383 VSS.n1382 211.446
R2963 VSS.n1332 VSS.n1331 204.55
R2964 VSS.n1376 VSS.n1375 180.12
R2965 VSS.n319 VSS.n318 178.814
R2966 VSS.n1483 VSS.t526 165.079
R2967 VSS.n1494 VSS.t524 165.079
R2968 VSS.n350 VSS.n349 163.127
R2969 VSS.n182 VSS.t566 152.136
R2970 VSS.n38 VSS.t563 152.136
R2971 VSS.n176 VSS.t565 149.395
R2972 VSS.n29 VSS.t564 149.395
R2973 VSS.n114 VSS.t489 144.445
R2974 VSS.t561 VSS.n110 144.445
R2975 VSS.n80 VSS.t125 144.445
R2976 VSS.n1506 VSS.t208 144.445
R2977 VSS.n1354 VSS.n1353 134.948
R2978 VSS.n1355 VSS.n1354 134.948
R2979 VSS.n1355 VSS.n305 134.948
R2980 VSS.n1361 VSS.n305 134.948
R2981 VSS.n1362 VSS.n1361 134.948
R2982 VSS.n1363 VSS.n1362 134.948
R2983 VSS.n1363 VSS.n300 134.948
R2984 VSS.n1369 VSS.n300 134.948
R2985 VSS.n1370 VSS.n1369 134.948
R2986 VSS.n1371 VSS.n1370 134.948
R2987 VSS.t252 VSS.t387 123.811
R2988 VSS.t516 VSS.t50 123.811
R2989 VSS.n1333 VSS.n1332 116.713
R2990 VSS.n349 VSS.n348 107.915
R2991 VSS.n370 VSS.n336 107.915
R2992 VSS.n374 VSS.n373 107.915
R2993 VSS.n376 VSS.n375 107.915
R2994 VSS.n383 VSS.n382 107.915
R2995 VSS.n385 VSS.n384 107.915
R2996 VSS.n1331 VSS.n322 107.915
R2997 VSS.n731 VSS.n730 91.219
R2998 VSS.n1332 VSS.n321 91.1502
R2999 VSS.n1409 VSS.n1408 91.0369
R3000 VSS.n946 VSS.n945 91.0369
R3001 VSS.n946 VSS.n561 91.0369
R3002 VSS.n909 VSS.n908 91.0369
R3003 VSS.n908 VSS.n578 91.0369
R3004 VSS.n1511 VSS.n65 87.5005
R3005 VSS.n1513 VSS.n69 87.5005
R3006 VSS.n70 VSS.n69 87.5005
R3007 VSS.n116 VSS.n115 87.5005
R3008 VSS.n115 VSS.n109 87.5005
R3009 VSS.n1473 VSS.n109 87.5005
R3010 VSS.n1473 VSS.n103 87.5005
R3011 VSS.n1477 VSS.n103 87.5005
R3012 VSS.n1477 VSS.n102 87.5005
R3013 VSS.n102 VSS.n97 87.5005
R3014 VSS.n97 VSS.n96 87.5005
R3015 VSS.n96 VSS.n95 87.5005
R3016 VSS.n95 VSS.n88 87.5005
R3017 VSS.n1495 VSS.n88 87.5005
R3018 VSS.n1495 VSS.n82 87.5005
R3019 VSS.n1499 VSS.n82 87.5005
R3020 VSS.n1499 VSS.n81 87.5005
R3021 VSS.n81 VSS.n76 87.5005
R3022 VSS.n76 VSS.n75 87.5005
R3023 VSS.n75 VSS.n74 87.5005
R3024 VSS.n74 VSS.n64 87.5005
R3025 VSS.n1455 VSS.n1454 87.5005
R3026 VSS.n1459 VSS.n1458 87.5005
R3027 VSS.n1467 VSS.n113 87.5005
R3028 VSS.n1467 VSS.n111 87.5005
R3029 VSS.n1471 VSS.n111 87.5005
R3030 VSS.n1471 VSS.n100 87.5005
R3031 VSS.n1478 VSS.n100 87.5005
R3032 VSS.n1478 VSS.n98 87.5005
R3033 VSS.n1482 VSS.n98 87.5005
R3034 VSS.n1482 VSS.n92 87.5005
R3035 VSS.n1489 VSS.n92 87.5005
R3036 VSS.n1489 VSS.n90 87.5005
R3037 VSS.n1493 VSS.n90 87.5005
R3038 VSS.n1493 VSS.n79 87.5005
R3039 VSS.n1500 VSS.n79 87.5005
R3040 VSS.n1500 VSS.n77 87.5005
R3041 VSS.n1504 VSS.n77 87.5005
R3042 VSS.n1504 VSS.n73 87.5005
R3043 VSS.n1508 VSS.n73 87.5005
R3044 VSS.n1508 VSS.n71 87.5005
R3045 VSS.n1006 VSS.n538 87.5005
R3046 VSS.n951 VSS.n538 87.5005
R3047 VSS.n951 VSS.n558 87.5005
R3048 VSS.n947 VSS.n558 87.5005
R3049 VSS.n947 VSS.n560 87.5005
R3050 VSS.n937 VSS.n560 87.5005
R3051 VSS.n937 VSS.n565 87.5005
R3052 VSS.n933 VSS.n565 87.5005
R3053 VSS.n933 VSS.n567 87.5005
R3054 VSS.n927 VSS.n567 87.5005
R3055 VSS.n927 VSS.n572 87.5005
R3056 VSS.n923 VSS.n572 87.5005
R3057 VSS.n923 VSS.n574 87.5005
R3058 VSS.n907 VSS.n574 87.5005
R3059 VSS.n907 VSS.n579 87.5005
R3060 VSS.n903 VSS.n579 87.5005
R3061 VSS.n903 VSS.n581 87.5005
R3062 VSS.n894 VSS.n581 87.5005
R3063 VSS.n875 VSS.n585 87.5005
R3064 VSS.n879 VSS.n872 87.5005
R3065 VSS.n882 VSS.n881 87.5005
R3066 VSS.n886 VSS.n869 87.5005
R3067 VSS.n890 VSS.n888 87.5005
R3068 VSS.n982 VSS.n537 87.5005
R3069 VSS.n982 VSS.n550 87.5005
R3070 VSS.n944 VSS.n550 87.5005
R3071 VSS.n944 VSS.n562 87.5005
R3072 VSS.n940 VSS.n562 87.5005
R3073 VSS.n940 VSS.n939 87.5005
R3074 VSS.n939 VSS.n564 87.5005
R3075 VSS.n568 VSS.n564 87.5005
R3076 VSS.n916 VSS.n568 87.5005
R3077 VSS.n916 VSS.n571 87.5005
R3078 VSS.n920 VSS.n571 87.5005
R3079 VSS.n920 VSS.n575 87.5005
R3080 VSS.n910 VSS.n575 87.5005
R3081 VSS.n910 VSS.n577 87.5005
R3082 VSS.n583 VSS.n577 87.5005
R3083 VSS.n901 VSS.n583 87.5005
R3084 VSS.n901 VSS.n582 87.5005
R3085 VSS.n896 VSS.n582 87.5005
R3086 VSS.n990 VSS.n548 87.5005
R3087 VSS.n993 VSS.n992 87.5005
R3088 VSS.n997 VSS.n545 87.5005
R3089 VSS.n1000 VSS.n999 87.5005
R3090 VSS.n132 VSS.n123 87.5005
R3091 VSS.n1415 VSS.n132 87.5005
R3092 VSS.n1415 VSS.n130 87.5005
R3093 VSS.n1410 VSS.n130 87.5005
R3094 VSS.n1410 VSS.n134 87.5005
R3095 VSS.n1401 VSS.n134 87.5005
R3096 VSS.n1401 VSS.n140 87.5005
R3097 VSS.n1397 VSS.n140 87.5005
R3098 VSS.n1397 VSS.n142 87.5005
R3099 VSS.n1186 VSS.n142 87.5005
R3100 VSS.n1186 VSS.n434 87.5005
R3101 VSS.n1190 VSS.n434 87.5005
R3102 VSS.n1190 VSS.n423 87.5005
R3103 VSS.n1224 VSS.n423 87.5005
R3104 VSS.n1224 VSS.n420 87.5005
R3105 VSS.n1228 VSS.n420 87.5005
R3106 VSS.n1228 VSS.n419 87.5005
R3107 VSS.n1053 VSS.n419 87.5005
R3108 VSS.n1072 VSS.n511 87.5005
R3109 VSS.n1055 VSS.n513 87.5005
R3110 VSS.n1058 VSS.n513 87.5005
R3111 VSS.n1062 VSS.n1061 87.5005
R3112 VSS.n1064 VSS.n516 87.5005
R3113 VSS.n517 VSS.n516 87.5005
R3114 VSS.n1421 VSS.n127 87.5005
R3115 VSS.n1417 VSS.n127 87.5005
R3116 VSS.n1417 VSS.n129 87.5005
R3117 VSS.n1407 VSS.n129 87.5005
R3118 VSS.n1407 VSS.n136 87.5005
R3119 VSS.n1403 VSS.n136 87.5005
R3120 VSS.n1403 VSS.n138 87.5005
R3121 VSS.n143 VSS.n138 87.5005
R3122 VSS.n1183 VSS.n143 87.5005
R3123 VSS.n1183 VSS.n435 87.5005
R3124 VSS.n1178 VSS.n435 87.5005
R3125 VSS.n1178 VSS.n433 87.5005
R3126 VSS.n1174 VSS.n433 87.5005
R3127 VSS.n1174 VSS.n425 87.5005
R3128 VSS.n1171 VSS.n425 87.5005
R3129 VSS.n1171 VSS.n414 87.5005
R3130 VSS.n1076 VSS.n414 87.5005
R3131 VSS.n1076 VSS.n509 87.5005
R3132 VSS.n1426 VSS.n1425 87.5005
R3133 VSS.n1430 VSS.n1429 87.5005
R3134 VSS.n1434 VSS.n1433 87.5005
R3135 VSS.n1438 VSS.n1437 87.5005
R3136 VSS.n1487 VSS.t223 82.5402
R3137 VSS.t371 VSS.n94 82.5402
R3138 VSS.n1377 VSS.n1373 77.0005
R3139 VSS.n1409 VSS.n135 72.8296
R3140 VSS.n326 VSS.n321 68.2505
R3141 VSS.n1522 VSS.n64 68.2505
R3142 VSS.n1451 VSS.n116 68.2505
R3143 VSS.n896 VSS.n585 68.2505
R3144 VSS.n986 VSS.n537 68.2505
R3145 VSS.n1072 VSS.n509 68.2505
R3146 VSS.n1422 VSS.n1421 68.2505
R3147 VSS.t435 VSS.t109 65.5467
R3148 VSS.t33 VSS.n139 65.5467
R3149 VSS.t454 VSS.n561 65.5467
R3150 VSS.n909 VSS.t194 65.5467
R3151 VSS.n1345 VSS.n293 65.0005
R3152 VSS.t233 VSS.n117 63.726
R3153 VSS.n895 VSS.t429 63.726
R3154 VSS.n1466 VSS.t518 61.9053
R3155 VSS.n1507 VSS.t514 61.9053
R3156 VSS.n1322 VSS.n1321 60.8596
R3157 VSS.n1192 VSS.t100 60.0845
R3158 VSS.n1352 VSS.n310 59.5005
R3159 VSS.n1217 VSS.n428 59.5005
R3160 VSS.n1271 VSS.n393 59.5005
R3161 VSS.n501 VSS.n473 59.5005
R3162 VSS.n1124 VSS.n474 59.5005
R3163 VSS.n797 VSS.n796 59.5005
R3164 VSS.n826 VSS.n610 59.5005
R3165 VSS.n1408 VSS.t295 56.4431
R3166 VSS.n945 VSS.t419 56.4431
R3167 VSS.t369 VSS.n578 56.4431
R3168 VSS.n348 VSS.t201 55.2129
R3169 VSS.t227 VSS.n336 55.2129
R3170 VSS.n371 VSS.t193 55.2129
R3171 VSS.n372 VSS.t444 55.2129
R3172 VSS.n374 VSS.t544 55.2129
R3173 VSS.n375 VSS.t541 55.2129
R3174 VSS.n335 VSS.t397 55.2129
R3175 VSS.t495 VSS.n331 55.2129
R3176 VSS.n383 VSS.t362 55.2129
R3177 VSS.n384 VSS.t228 55.2129
R3178 VSS.t373 VSS.n1325 55.2129
R3179 VSS.n1324 VSS.t410 55.2129
R3180 VSS.n1321 VSS.t307 55.2129
R3181 VSS.t427 VSS.n322 55.2129
R3182 VSS.n1032 VSS.n394 54.6223
R3183 VSS.n1023 VSS.n1022 54.6223
R3184 VSS.t408 VSS.n551 54.6223
R3185 VSS.n689 VSS.n637 54.6223
R3186 VSS.n675 VSS.n648 54.6223
R3187 VSS.n369 VSS.n338 52.5005
R3188 VSS.n369 VSS.n337 52.5005
R3189 VSS.n337 VSS.n334 52.5005
R3190 VSS.n377 VSS.n334 52.5005
R3191 VSS.n377 VSS.n332 52.5005
R3192 VSS.n381 VSS.n332 52.5005
R3193 VSS.n381 VSS.n330 52.5005
R3194 VSS.n1326 VSS.n330 52.5005
R3195 VSS.n1326 VSS.n323 52.5005
R3196 VSS.n1330 VSS.n323 52.5005
R3197 VSS.n1330 VSS.n321 52.5005
R3198 VSS.n1348 VSS.n310 52.5005
R3199 VSS.n1348 VSS.n1346 52.5005
R3200 VSS.n1346 VSS.n312 52.5005
R3201 VSS.n355 VSS.n312 52.5005
R3202 VSS.n355 VSS.n353 52.5005
R3203 VSS.n359 VSS.n353 52.5005
R3204 VSS.n362 VSS.n361 52.5005
R3205 VSS.n1352 VSS.n308 52.5005
R3206 VSS.n1356 VSS.n308 52.5005
R3207 VSS.n1356 VSS.n306 52.5005
R3208 VSS.n1360 VSS.n306 52.5005
R3209 VSS.n1360 VSS.n304 52.5005
R3210 VSS.n1364 VSS.n304 52.5005
R3211 VSS.n1364 VSS.n301 52.5005
R3212 VSS.n1368 VSS.n301 52.5005
R3213 VSS.n1368 VSS.n298 52.5005
R3214 VSS.n1372 VSS.n298 52.5005
R3215 VSS.n1373 VSS.n1372 52.5005
R3216 VSS.n1377 VSS.n295 52.5005
R3217 VSS.n1381 VSS.n295 52.5005
R3218 VSS.n1381 VSS.n294 52.5005
R3219 VSS.n1339 VSS.n294 52.5005
R3220 VSS.n1335 VSS.n315 52.5005
R3221 VSS.n324 VSS.n317 52.5005
R3222 VSS.n1283 VSS.n1282 52.5005
R3223 VSS.n1284 VSS.n1283 52.5005
R3224 VSS.n1288 VSS.n1279 52.5005
R3225 VSS.n1291 VSS.n1290 52.5005
R3226 VSS.n1295 VSS.n1276 52.5005
R3227 VSS.n1199 VSS.n288 52.5005
R3228 VSS.n1203 VSS.n1202 52.5005
R3229 VSS.n1211 VSS.n1210 52.5005
R3230 VSS.n1215 VSS.n1214 52.5005
R3231 VSS.n1221 VSS.n428 52.5005
R3232 VSS.n1221 VSS.n427 52.5005
R3233 VSS.n1170 VSS.n427 52.5005
R3234 VSS.n1170 VSS.n439 52.5005
R3235 VSS.n1166 VSS.n439 52.5005
R3236 VSS.n1166 VSS.n441 52.5005
R3237 VSS.n1046 VSS.n441 52.5005
R3238 VSS.n1051 VSS.n1046 52.5005
R3239 VSS.n1051 VSS.n1041 52.5005
R3240 VSS.n1041 VSS.n396 52.5005
R3241 VSS.n1308 VSS.n1307 52.5005
R3242 VSS.n1312 VSS.n1311 52.5005
R3243 VSS.n1314 VSS.n390 52.5005
R3244 VSS.n1318 VSS.n391 52.5005
R3245 VSS.n499 VSS.n485 52.5005
R3246 VSS.n495 VSS.n493 52.5005
R3247 VSS.n491 VSS.n488 52.5005
R3248 VSS.n1144 VSS.n1143 52.5005
R3249 VSS.n1148 VSS.n458 52.5005
R3250 VSS.n1151 VSS.n1150 52.5005
R3251 VSS.n1095 VSS.n1093 52.5005
R3252 VSS.n1091 VSS.n476 52.5005
R3253 VSS.n1087 VSS.n1085 52.5005
R3254 VSS.n1112 VSS.n1109 52.5005
R3255 VSS.n1107 VSS.n1098 52.5005
R3256 VSS.n1103 VSS.n1101 52.5005
R3257 VSS.n786 VSS.n785 52.5005
R3258 VSS.n782 VSS.n781 52.5005
R3259 VSS.n778 VSS.n777 52.5005
R3260 VSS.n751 VSS.n594 52.5005
R3261 VSS.n755 VSS.n754 52.5005
R3262 VSS.n759 VSS.n758 52.5005
R3263 VSS.n630 VSS.n616 52.5005
R3264 VSS.n702 VSS.n630 52.5005
R3265 VSS.n702 VSS.n628 52.5005
R3266 VSS.n697 VSS.n628 52.5005
R3267 VSS.n697 VSS.n632 52.5005
R3268 VSS.n688 VSS.n632 52.5005
R3269 VSS.n688 VSS.n639 52.5005
R3270 VSS.n684 VSS.n639 52.5005
R3271 VSS.n684 VSS.n641 52.5005
R3272 VSS.n674 VSS.n641 52.5005
R3273 VSS.n661 VSS.n654 52.5005
R3274 VSS.n664 VSS.n663 52.5005
R3275 VSS.n668 VSS.n667 52.5005
R3276 VSS.n670 VSS.n668 52.5005
R3277 VSS.n708 VSS.n624 52.5005
R3278 VSS.n704 VSS.n624 52.5005
R3279 VSS.n704 VSS.n626 52.5005
R3280 VSS.n694 VSS.n626 52.5005
R3281 VSS.n694 VSS.n634 52.5005
R3282 VSS.n690 VSS.n634 52.5005
R3283 VSS.n690 VSS.n636 52.5005
R3284 VSS.n680 VSS.n636 52.5005
R3285 VSS.n680 VSS.n642 52.5005
R3286 VSS.n676 VSS.n642 52.5005
R3287 VSS.n717 VSS.n716 52.5005
R3288 VSS.n721 VSS.n720 52.5005
R3289 VSS.n725 VSS.n724 52.5005
R3290 VSS.n729 VSS.n617 52.5005
R3291 VSS.n826 VSS.n609 52.5005
R3292 VSS.n814 VSS.n738 52.5005
R3293 VSS.n817 VSS.n738 52.5005
R3294 VSS.n819 VSS.n740 52.5005
R3295 VSS.n838 VSS.n837 52.5005
R3296 VSS.n842 VSS.n841 52.5005
R3297 VSS.n846 VSS.n845 52.5005
R3298 VSS.n1256 VSS.n403 52.5005
R3299 VSS.n1256 VSS.n400 52.5005
R3300 VSS.n1260 VSS.n400 52.5005
R3301 VSS.n1260 VSS.n399 52.5005
R3302 VSS.n1027 VSS.n399 52.5005
R3303 VSS.n1027 VSS.n523 52.5005
R3304 VSS.n1031 VSS.n523 52.5005
R3305 VSS.n1031 VSS.n522 52.5005
R3306 VSS.n1024 VSS.n522 52.5005
R3307 VSS.n1024 VSS.n525 52.5005
R3308 VSS.n1014 VSS.n525 52.5005
R3309 VSS.n1014 VSS.n532 52.5005
R3310 VSS.n1010 VSS.n532 52.5005
R3311 VSS.n1010 VSS.n534 52.5005
R3312 VSS.n957 VSS.n534 52.5005
R3313 VSS.n960 VSS.n557 52.5005
R3314 VSS.n964 VSS.n963 52.5005
R3315 VSS.n966 VSS.n955 52.5005
R3316 VSS.n956 VSS.n955 52.5005
R3317 VSS.n1255 VSS.n407 52.5005
R3318 VSS.n1255 VSS.n406 52.5005
R3319 VSS.n406 VSS.n397 52.5005
R3320 VSS.n1039 VSS.n397 52.5005
R3321 VSS.n1039 VSS.n519 52.5005
R3322 VSS.n1034 VSS.n519 52.5005
R3323 VSS.n1034 VSS.n1033 52.5005
R3324 VSS.n1033 VSS.n521 52.5005
R3325 VSS.n1021 VSS.n521 52.5005
R3326 VSS.n1021 VSS.n526 52.5005
R3327 VSS.n1016 VSS.n526 52.5005
R3328 VSS.n1016 VSS.n528 52.5005
R3329 VSS.n536 VSS.n528 52.5005
R3330 VSS.n980 VSS.n536 52.5005
R3331 VSS.n980 VSS.n552 52.5005
R3332 VSS.n1235 VSS.n413 52.5005
R3333 VSS.n1239 VSS.n1238 52.5005
R3334 VSS.n1243 VSS.n1242 52.5005
R3335 VSS.n1247 VSS.n1233 52.5005
R3336 VSS.n1184 VSS.t83 50.9809
R3337 VSS.n915 VSS.t182 50.9809
R3338 VSS.t30 VSS.n611 50.9809
R3339 VSS.n689 VSS.t474 50.9809
R3340 VSS.n1342 VSS.t32 50.7817
R3341 VSS.n364 VSS.n338 50.7505
R3342 VSS.n1463 VSS.n113 50.7505
R3343 VSS.n1518 VSS.n71 50.7505
R3344 VSS.n1386 VSS.n1385 50.7505
R3345 VSS.n1299 VSS.n1298 50.7505
R3346 VSS.n709 VSS.n708 50.7505
R3347 VSS.n729 VSS.n616 50.7505
R3348 VSS.n975 VSS.n552 50.7505
R3349 VSS.n1250 VSS.n407 50.7505
R3350 VSS.n894 VSS.n867 50.7505
R3351 VSS.n1006 VSS.n539 50.7505
R3352 VSS.n1069 VSS.n1053 50.7505
R3353 VSS.n1442 VSS.n123 50.7505
R3354 VSS.t351 VSS.n386 47.5215
R3355 VSS.n1323 VSS.n1322 47.0565
R3356 VSS.n1463 VSS.n1448 43.7505
R3357 VSS.n1125 VSS.n469 42.0005
R3358 VSS.n1141 VSS.n452 42.0005
R3359 VSS.n1083 VSS.n471 42.0005
R3360 VSS.n1110 VSS.n451 42.0005
R3361 VSS.n774 VSS.n747 42.0005
R3362 VSS.n862 VSS.n595 42.0005
R3363 VSS.n674 VSS.n649 42.0005
R3364 VSS.n676 VSS.n644 42.0005
R3365 VSS.n823 VSS.n741 42.0005
R3366 VSS.n856 VSS.n855 42.0005
R3367 VSS.n971 VSS.n957 42.0005
R3368 VSS.n1247 VSS.n403 42.0005
R3369 VSS.n1443 VSS.n117 41.8773
R3370 VSS.t119 VSS.n144 41.8773
R3371 VSS.n1177 VSS.t148 41.8773
R3372 VSS.t389 VSS.n569 41.8773
R3373 VSS.n921 VSS.t483 41.8773
R3374 VSS.n895 VSS.n865 41.8773
R3375 VSS.n825 VSS.n732 41.8773
R3376 VSS.t518 VSS.t456 41.2703
R3377 VSS.t456 VSS.t467 41.2703
R3378 VSS.t489 VSS.t462 41.2703
R3379 VSS.t462 VSS.t460 41.2703
R3380 VSS.t460 VSS.t491 41.2703
R3381 VSS.t555 VSS.t557 41.2703
R3382 VSS.t557 VSS.t559 41.2703
R3383 VSS.t559 VSS.t561 41.2703
R3384 VSS.t255 VSS.t257 41.2703
R3385 VSS.t257 VSS.t28 41.2703
R3386 VSS.t28 VSS.t24 41.2703
R3387 VSS.t24 VSS.t22 41.2703
R3388 VSS.t22 VSS.t92 41.2703
R3389 VSS.t266 VSS.t92 41.2703
R3390 VSS.t266 VSS.t260 41.2703
R3391 VSS.t270 VSS.t268 41.2703
R3392 VSS.t86 VSS.t270 41.2703
R3393 VSS.t85 VSS.t86 41.2703
R3394 VSS.t37 VSS.t36 41.2703
R3395 VSS.t36 VSS.t262 41.2703
R3396 VSS.t262 VSS.t252 41.2703
R3397 VSS.t387 VSS.t465 41.2703
R3398 VSS.t465 VSS.t526 41.2703
R3399 VSS.t524 VSS.t522 41.2703
R3400 VSS.t522 VSS.t516 41.2703
R3401 VSS.t50 VSS.t57 41.2703
R3402 VSS.t57 VSS.t59 41.2703
R3403 VSS.t59 VSS.t19 41.2703
R3404 VSS.t17 VSS.t62 41.2703
R3405 VSS.t62 VSS.t66 41.2703
R3406 VSS.t66 VSS.t64 41.2703
R3407 VSS.t40 VSS.t38 41.2703
R3408 VSS.t40 VSS.t42 41.2703
R3409 VSS.t46 VSS.t42 41.2703
R3410 VSS.t44 VSS.t46 41.2703
R3411 VSS.t48 VSS.t44 41.2703
R3412 VSS.t52 VSS.t48 41.2703
R3413 VSS.t54 VSS.t52 41.2703
R3414 VSS.t125 VSS.t127 41.2703
R3415 VSS.t127 VSS.t123 41.2703
R3416 VSS.t123 VSS.t129 41.2703
R3417 VSS.t204 VSS.t202 41.2703
R3418 VSS.t206 VSS.t204 41.2703
R3419 VSS.t208 VSS.t206 41.2703
R3420 VSS.t452 VSS.t520 41.2703
R3421 VSS.t514 VSS.t452 41.2703
R3422 VSS.n438 VSS.n437 39.9818
R3423 VSS.n318 VSS.n289 39.1571
R3424 VSS.t384 VSS.t545 36.4151
R3425 VSS.t308 VSS.t542 36.4151
R3426 VSS.t305 VSS.t551 36.4151
R3427 VSS.t168 VSS.t212 36.4151
R3428 VSS.n853 VSS.n586 36.4151
R3429 VSS.n1298 VSS.n1297 35.0005
R3430 VSS.n396 VSS.n393 35.0005
R3431 VSS.n1155 VSS.n417 35.0005
R3432 VSS.n444 VSS.n417 35.0005
R3433 VSS.n1130 VSS.n444 35.0005
R3434 VSS.n1130 VSS.n467 35.0005
R3435 VSS.n1125 VSS.n467 35.0005
R3436 VSS.n452 VSS.n416 35.0005
R3437 VSS.n443 VSS.n416 35.0005
R3438 VSS.n466 VSS.n443 35.0005
R3439 VSS.n508 VSS.n466 35.0005
R3440 VSS.n508 VSS.n473 35.0005
R3441 VSS.n1157 VSS.n418 35.0005
R3442 VSS.n1161 VSS.n418 35.0005
R3443 VSS.n1161 VSS.n445 35.0005
R3444 VSS.n1079 VSS.n445 35.0005
R3445 VSS.n1079 VSS.n471 35.0005
R3446 VSS.n451 VSS.n415 35.0005
R3447 VSS.n442 VSS.n415 35.0005
R3448 VSS.n1132 VSS.n442 35.0005
R3449 VSS.n1132 VSS.n465 35.0005
R3450 VSS.n1124 VSS.n465 35.0005
R3451 VSS.n763 VSS.n603 35.0005
R3452 VSS.n805 VSS.n603 35.0005
R3453 VSS.n805 VSS.n748 35.0005
R3454 VSS.n809 VSS.n748 35.0005
R3455 VSS.n809 VSS.n747 35.0005
R3456 VSS.n602 VSS.n595 35.0005
R3457 VSS.n803 VSS.n602 35.0005
R3458 VSS.n803 VSS.n773 35.0005
R3459 VSS.n773 VSS.n746 35.0005
R3460 VSS.n797 VSS.n746 35.0005
R3461 VSS.n852 VSS.n605 35.0005
R3462 VSS.n852 VSS.n604 35.0005
R3463 VSS.n743 VSS.n604 35.0005
R3464 VSS.n811 VSS.n743 35.0005
R3465 VSS.n811 VSS.n741 35.0005
R3466 VSS.n856 VSS.n854 35.0005
R3467 VSS.n854 VSS.n600 35.0005
R3468 VSS.n771 VSS.n600 35.0005
R3469 VSS.n771 VSS.n745 35.0005
R3470 VSS.n745 VSS.n610 35.0005
R3471 VSS.n1396 VSS.t81 32.7736
R3472 VSS.n928 VSS.t184 32.7736
R3473 VSS.n1394 VSS.n145 29.6637
R3474 VSS.n931 VSS.n930 29.6637
R3475 VSS.n1486 VSS.n1485 29.6637
R3476 VSS.n744 VSS.n732 29.3142
R3477 VSS.t331 VSS.n1184 29.1322
R3478 VSS.n915 VSS.t538 29.1322
R3479 VSS.n623 VSS.n1 28.4449
R3480 VSS.n1395 VSS.n1394 28.4005
R3481 VSS.n930 VSS.n929 28.4005
R3482 VSS.n1485 VSS.n1484 28.4005
R3483 VSS.n1032 VSS.n93 27.3114
R3484 VSS.n1022 VSS.n93 27.3114
R3485 VSS.n1222 VSS.n426 26.5019
R3486 VSS.n1002 VSS.n539 26.2505
R3487 VSS.n1442 VSS.n124 26.2505
R3488 VSS.t201 VSS.t395 25.097
R3489 VSS.t395 VSS.t227 25.097
R3490 VSS.t345 VSS.t193 25.097
R3491 VSS.t345 VSS.t444 25.097
R3492 VSS.t544 VSS.t0 25.097
R3493 VSS.t0 VSS.t541 25.097
R3494 VSS.t397 VSS.t310 25.097
R3495 VSS.t310 VSS.t495 25.097
R3496 VSS.t362 VSS.t481 25.097
R3497 VSS.t481 VSS.t228 25.097
R3498 VSS.t118 VSS.t373 25.097
R3499 VSS.t118 VSS.t410 25.097
R3500 VSS.t307 VSS.t68 25.097
R3501 VSS.t68 VSS.t427 25.097
R3502 VSS.n243 VSS.n242 24.6095
R3503 VSS.n245 VSS.n244 24.6095
R3504 VSS.n1155 VSS.n454 24.5005
R3505 VSS.n1157 VSS.n448 24.5005
R3506 VSS.n763 VSS.n762 24.5005
R3507 VSS.n848 VSS.n605 24.5005
R3508 VSS.n1395 VSS.t120 23.67
R3509 VSS.t147 VSS.n145 23.67
R3510 VSS.n1156 VSS.n453 23.67
R3511 VSS.n1023 VSS.t12 23.67
R3512 VSS.n931 VSS.t390 23.67
R3513 VSS.n929 VSS.t482 23.67
R3514 VSS.n864 VSS.n586 23.67
R3515 VSS.n730 VSS.n611 23.67
R3516 VSS.n1383 VSS.n289 23.4945
R3517 VSS.t1 VSS.t95 21.8492
R3518 VSS.t235 VSS.t7 21.8492
R3519 VSS.n1252 VSS.n284 21.3764
R3520 VSS.n1393 VSS.n126 21.0663
R3521 VSS.n584 VSS.n570 21.0663
R3522 VSS.n1464 VSS.n1444 20.6354
R3523 VSS.n101 VSS.t85 20.6354
R3524 VSS.n101 VSS.t37 20.6354
R3525 VSS.n1486 VSS.t225 20.6354
R3526 VSS.t223 VSS.n1486 20.6354
R3527 VSS.n1484 VSS.t371 20.6354
R3528 VSS.n1484 VSS.t188 20.6354
R3529 VSS.t19 VSS.n89 20.6354
R3530 VSS.n89 VSS.t17 20.6354
R3531 VSS.n1520 VSS.n66 20.6354
R3532 VSS.n859 VSS.n858 20.0894
R3533 VSS.n1269 VSS.t177 20.0285
R3534 VSS.n366 VSS.n346 20.0247
R3535 VSS.n1389 VSS.n1388 19.8527
R3536 VSS.n1382 VSS.n293 19.5788
R3537 VSS.n187 VSS.n186 19.4957
R3538 VSS.n43 VSS.n42 19.4957
R3539 VSS.n164 VSS.n163 19.3062
R3540 VSS.n20 VSS.n19 19.3062
R3541 VSS.n1138 VSS.n1137 19.1783
R3542 VSS.n1139 VSS.n1138 18.8227
R3543 VSS.n206 VSS.n205 18.5483
R3544 VSS.n283 VSS.n282 18.5483
R3545 VSS.n151 VSS.n150 18.4989
R3546 VSS.n7 VSS.n6 18.4989
R3547 VSS.n139 VSS.n135 18.2078
R3548 VSS.n1396 VSS.n1395 18.2078
R3549 VSS.n1185 VSS.n145 18.2078
R3550 VSS.n432 VSS.n431 18.2078
R3551 VSS.n1223 VSS.n1222 18.2078
R3552 VSS.n932 VSS.n931 18.2078
R3553 VSS.n929 VSS.n928 18.2078
R3554 VSS.t31 VSS.n627 18.1864
R3555 VSS.t473 VSS.n633 18.1864
R3556 VSS.t353 VSS.n386 18.0257
R3557 VSS.n860 VSS.n859 18.0005
R3558 VSS.n157 VSS.n151 16.9831
R3559 VSS.n160 VSS.n159 16.9831
R3560 VSS.n194 VSS.n188 16.9831
R3561 VSS.n197 VSS.n196 16.9831
R3562 VSS.n203 VSS.n202 16.9831
R3563 VSS.n59 VSS.n58 16.9831
R3564 VSS.n53 VSS.n52 16.9831
R3565 VSS.n51 VSS.n44 16.9831
R3566 VSS.n16 VSS.n15 16.9831
R3567 VSS.n14 VSS.n7 16.9831
R3568 VSS.n530 VSS.t13 16.5691
R3569 VSS.t500 VSS.n1261 16.3871
R3570 VSS.n1015 VSS.t506 16.3871
R3571 VSS.t512 VSS.n542 16.3871
R3572 VSS.n453 VSS.n438 16.3123
R3573 VSS.n180 VSS.n179 15.8092
R3574 VSS.n36 VSS.n35 15.8092
R3575 VSS.n1528 VSS.n1527 15.7055
R3576 VSS.n258 VSS.n247 15.2627
R3577 VSS.n216 VSS.n215 15.2222
R3578 VSS.n274 VSS.n273 15.2222
R3579 VSS.n340 VSS.t237 15.202
R3580 VSS.n1322 VSS.n1320 15.1168
R3581 VSS.t191 VSS.t135 14.5663
R3582 VSS.t220 VSS.t136 14.5663
R3583 VSS.t190 VSS.t99 14.5663
R3584 VSS.n703 VSS.t94 14.5663
R3585 VSS.n696 VSS.t236 14.5663
R3586 VSS.n675 VSS.n645 14.5663
R3587 VSS.n1390 VSS.n0 14.4602
R3588 VSS.n340 VSS.t186 14.302
R3589 VSS.n341 VSS.t180 14.302
R3590 VSS.n342 VSS.t15 14.302
R3591 VSS.n343 VSS.t529 14.302
R3592 VSS.n344 VSS.t528 14.302
R3593 VSS.n345 VSS.t396 14.302
R3594 VSS.n211 VSS.n207 13.793
R3595 VSS.n279 VSS.n275 13.793
R3596 VSS.n556 VSS.n555 13.5139
R3597 VSS.n412 VSS.n411 13.5139
R3598 VSS.n1525 VSS.n1524 13.5005
R3599 VSS.n220 VSS.n217 13.2657
R3600 VSS.n263 VSS.n260 13.2657
R3601 VSS.n714 VSS.n713 13.022
R3602 VSS.n622 VSS.n621 13.022
R3603 VSS.n226 VSS.n218 12.9149
R3604 VSS.n269 VSS.n261 12.9149
R3605 VSS.t96 VSS.n470 12.5635
R3606 VSS.t393 VSS.n601 12.5635
R3607 VSS.n767 VSS.t111 12.5635
R3608 VSS.n681 VSS.t101 12.5635
R3609 VSS.n682 VSS.t102 12.5635
R3610 VSS.n646 VSS.t428 12.5635
R3611 VSS.n647 VSS.t443 12.5635
R3612 VSS.n250 VSS.n249 12.4151
R3613 VSS.n659 VSS.n658 12.392
R3614 VSS.n1267 VSS.t471 11.6532
R3615 VSS.t398 VSS.n535 11.1069
R3616 VSS.n853 VSS.n601 11.1069
R3617 VSS.n234 VSS.n228 11.0126
R3618 VSS.n1185 VSS.t343 10.9249
R3619 VSS.t97 VSS.t149 10.9249
R3620 VSS.t134 VSS.t122 10.9249
R3621 VSS.t484 VSS.t137 10.9249
R3622 VSS.t98 VSS.t392 10.9249
R3623 VSS.t417 VSS.n551 10.9249
R3624 VSS.n932 VSS.t531 10.9249
R3625 VSS.n212 VSS.n211 10.7222
R3626 VSS.n280 VSS.n279 10.7222
R3627 VSS.n1391 VSS.n1390 10.2826
R3628 VSS.n1115 VSS.n1114 10.2705
R3629 VSS.n1121 VSS.n1120 10.2705
R3630 VSS.n478 VSS.n461 10.2705
R3631 VSS.n484 VSS.n483 10.2705
R3632 VSS.n788 VSS.n596 10.2705
R3633 VSS.n794 VSS.n793 10.2705
R3634 VSS.n835 VSS.n834 10.2705
R3635 VSS.n829 VSS.n828 10.2705
R3636 VSS.n182 VSS.n181 9.98011
R3637 VSS.n38 VSS.n37 9.98011
R3638 VSS.n232 VSS.n231 9.98011
R3639 VSS.n1163 VSS.t152 9.28621
R3640 VSS.t71 VSS.n766 9.28621
R3641 VSS.t77 VSS.n767 9.28621
R3642 VSS.t141 VSS.n682 9.28621
R3643 VSS.n646 VSS.t139 9.28621
R3644 VSS.n1045 VSS.t281 9.10414
R3645 VSS.t221 VSS.n472 9.10414
R3646 VSS.t251 VSS.n1040 9.10414
R3647 VSS.n529 VSS.t220 9.10414
R3648 VSS.n1009 VSS.t190 9.10414
R3649 VSS.n227 VSS.n226 8.76572
R3650 VSS.n270 VSS.n269 8.76572
R3651 VSS.n175 VSS.n165 8.57007
R3652 VSS.n183 VSS.n182 8.57007
R3653 VSS.n28 VSS.n21 8.57007
R3654 VSS.n39 VSS.n38 8.57007
R3655 VSS.n431 VSS.n426 8.29465
R3656 VSS.n232 VSS.n230 7.51148
R3657 VSS.n424 VSS.t166 7.32154
R3658 VSS.t167 VSS.n438 7.32154
R3659 VSS.n627 VSS.t192 7.29487
R3660 VSS.n633 VSS.t133 7.29487
R3661 VSS.t231 VSS.t233 7.28341
R3662 VSS.t441 VSS.t231 7.28341
R3663 VSS.t439 VSS.t441 7.28341
R3664 VSS.t437 VSS.t435 7.28341
R3665 VSS.t109 VSS.t107 7.28341
R3666 VSS.t107 VSS.t105 7.28341
R3667 VSS.t301 VSS.t103 7.28341
R3668 VSS.t299 VSS.t301 7.28341
R3669 VSS.t297 VSS.t299 7.28341
R3670 VSS.t295 VSS.t297 7.28341
R3671 VSS.t89 VSS.t33 7.28341
R3672 VSS.t90 VSS.t89 7.28341
R3673 VSS.t450 VSS.t90 7.28341
R3674 VSS.t93 VSS.t9 7.28341
R3675 VSS.t545 VSS.t547 7.28341
R3676 VSS.t383 VSS.t384 7.28341
R3677 VSS.t382 VSS.t383 7.28341
R3678 VSS.t120 VSS.t119 7.28341
R3679 VSS.t83 VSS.t81 7.28341
R3680 VSS.t333 VSS.t331 7.28341
R3681 VSS.t335 VSS.t333 7.28341
R3682 VSS.t337 VSS.t335 7.28341
R3683 VSS.t329 VSS.t337 7.28341
R3684 VSS.t339 VSS.t329 7.28341
R3685 VSS.t341 VSS.t339 7.28341
R3686 VSS.t343 VSS.t341 7.28341
R3687 VSS.t148 VSS.t147 7.28341
R3688 VSS.t381 VSS.t380 7.28341
R3689 VSS.t380 VSS.t308 7.28341
R3690 VSS.t542 VSS.t218 7.28341
R3691 VSS.t386 VSS.t210 7.28341
R3692 VSS.t385 VSS.t181 7.28341
R3693 VSS.t16 VSS.t385 7.28341
R3694 VSS.t100 VSS.t16 7.28341
R3695 VSS.t291 VSS.t293 7.28341
R3696 VSS.t154 VSS.t152 7.28341
R3697 VSS.t156 VSS.t154 7.28341
R3698 VSS.t498 VSS.t500 7.28341
R3699 VSS.t251 VSS.t504 7.28341
R3700 VSS.t13 VSS.t12 7.28341
R3701 VSS.t485 VSS.t484 7.28341
R3702 VSS.t508 VSS.t510 7.28341
R3703 VSS.t510 VSS.t512 7.28341
R3704 VSS.t402 VSS.t404 7.28341
R3705 VSS.t400 VSS.t408 7.28341
R3706 VSS.t415 VSS.t417 7.28341
R3707 VSS.t425 VSS.t411 7.28341
R3708 VSS.t423 VSS.t425 7.28341
R3709 VSS.t421 VSS.t423 7.28341
R3710 VSS.t419 VSS.t421 7.28341
R3711 VSS.t464 VSS.t454 7.28341
R3712 VSS.t35 VSS.t464 7.28341
R3713 VSS.t164 VSS.t35 7.28341
R3714 VSS.t549 VSS.t131 7.28341
R3715 VSS.t551 VSS.t553 7.28341
R3716 VSS.t304 VSS.t305 7.28341
R3717 VSS.t303 VSS.t304 7.28341
R3718 VSS.t390 VSS.t389 7.28341
R3719 VSS.t238 VSS.t531 7.28341
R3720 VSS.t240 VSS.t238 7.28341
R3721 VSS.t244 VSS.t240 7.28341
R3722 VSS.t246 VSS.t244 7.28341
R3723 VSS.t248 VSS.t246 7.28341
R3724 VSS.t242 VSS.t248 7.28341
R3725 VSS.t538 VSS.t242 7.28341
R3726 VSS.t182 VSS.t184 7.28341
R3727 VSS.t483 VSS.t482 7.28341
R3728 VSS.t213 VSS.t550 7.28341
R3729 VSS.t212 VSS.t213 7.28341
R3730 VSS.t174 VSS.t168 7.28341
R3731 VSS.t455 VSS.t469 7.28341
R3732 VSS.t540 VSS.t138 7.28341
R3733 VSS.t117 VSS.t540 7.28341
R3734 VSS.t194 VSS.t117 7.28341
R3735 VSS.t367 VSS.t369 7.28341
R3736 VSS.t365 VSS.t367 7.28341
R3737 VSS.t363 VSS.t365 7.28341
R3738 VSS.t359 VSS.t363 7.28341
R3739 VSS.t357 VSS.t355 7.28341
R3740 VSS.t355 VSS.t353 7.28341
R3741 VSS.t349 VSS.t351 7.28341
R3742 VSS.t433 VSS.t347 7.28341
R3743 VSS.t431 VSS.t433 7.28341
R3744 VSS.t429 VSS.t431 7.28341
R3745 VSS.t69 VSS.t71 7.28341
R3746 VSS.t73 VSS.t69 7.28341
R3747 VSS.t95 VSS.t94 7.28341
R3748 VSS.t3 VSS.t1 7.28341
R3749 VSS.t7 VSS.t5 7.28341
R3750 VSS.t236 VSS.t235 7.28341
R3751 VSS.t143 VSS.t141 7.28341
R3752 VSS.t139 VSS.t145 7.28341
R3753 VSS.n346 VSS.n0 7.16497
R3754 VSS.n1163 VSS.n1162 7.10134
R3755 VSS.n1043 VSS.n472 7.10134
R3756 VSS.n1264 VSS.n395 7.10134
R3757 VSS.n530 VSS.n529 7.10134
R3758 VSS.n1009 VSS.n535 7.10134
R3759 VSS.n804 VSS.n766 7.10134
R3760 VSS.n810 VSS.n744 7.10134
R3761 VSS.n825 VSS.n731 7.10134
R3762 VSS.n1485 VSS.n61 6.8599
R3763 VSS.n1194 VSS.t325 6.57557
R3764 VSS.n1266 VSS.t191 6.55512
R3765 VSS.n1119 VSS.n1116 6.5388
R3766 VSS.n1118 VSS.n1117 6.5388
R3767 VSS.n482 VSS.n479 6.5388
R3768 VSS.n481 VSS.n480 6.5388
R3769 VSS.n792 VSS.n789 6.5388
R3770 VSS.n791 VSS.n790 6.5388
R3771 VSS.n831 VSS.n830 6.5388
R3772 VSS.n833 VSS.n832 6.5388
R3773 VSS.n1207 VSS.n1205 6.49615
R3774 VSS.n1304 VSS.t328 6.45713
R3775 VSS.n241 VSS.n240 6.41789
R3776 VSS.n259 VSS.n258 6.41789
R3777 VSS.n250 VSS.n246 6.41789
R3778 VSS.n1303 VSS.n1302 6.41078
R3779 VSS.n555 VSS.n553 6.38826
R3780 VSS.n411 VSS.n410 6.38826
R3781 VSS.n658 VSS.n656 6.3881
R3782 VSS.n658 VSS.n657 6.38518
R3783 VSS.n555 VSS.n554 6.38502
R3784 VSS.n411 VSS.n409 6.38502
R3785 VSS.n1207 VSS.n1206 6.31615
R3786 VSS.n1194 VSS.n1193 6.29483
R3787 VSS.n1303 VSS.n1301 6.29483
R3788 VSS.n1196 VSS.n1195 6.29333
R3789 VSS.n1208 VSS.n1207 6.278
R3790 VSS.n188 VSS.n187 6.20576
R3791 VSS.n44 VSS.n43 6.20576
R3792 VSS.n449 VSS.t289 6.19098
R3793 VSS.n1391 VSS.n283 6.1385
R3794 VSS.n1526 VSS.n1525 5.8145
R3795 VSS.n859 VSS.n1 5.81161
R3796 VSS.n249 VSS.t527 5.7796
R3797 VSS.n713 VSS.n712 5.73984
R3798 VSS.n621 VSS.n620 5.73984
R3799 VSS.n713 VSS.n711 5.73692
R3800 VSS.n621 VSS.n619 5.73692
R3801 VSS.n1197 VSS.n1196 5.6555
R3802 VSS.n1262 VSS.t498 5.64476
R3803 VSS.t122 VSS.n1263 5.64476
R3804 VSS.n1265 VSS.t134 5.64476
R3805 VSS.t137 VSS.n531 5.64476
R3806 VSS.n1008 VSS.t98 5.64476
R3807 VSS.n205 VSS.t515 5.63749
R3808 VSS.n282 VSS.t468 5.63749
R3809 VSS.n1305 VSS.n1304 5.5955
R3810 VSS.n230 VSS.t517 5.59012
R3811 VSS.n148 VSS.n146 5.57485
R3812 VSS.n154 VSS.n152 5.57485
R3813 VSS.n163 VSS.n161 5.57485
R3814 VSS.n168 VSS.n166 5.57485
R3815 VSS.n172 VSS.n170 5.57485
R3816 VSS.n191 VSS.n189 5.57485
R3817 VSS.n200 VSS.n198 5.57485
R3818 VSS.n186 VSS.n184 5.57485
R3819 VSS.n57 VSS.n55 5.57485
R3820 VSS.n48 VSS.n46 5.57485
R3821 VSS.n42 VSS.n40 5.57485
R3822 VSS.n26 VSS.n24 5.57485
R3823 VSS.n32 VSS.n30 5.57485
R3824 VSS.n11 VSS.n9 5.57485
R3825 VSS.n5 VSS.n3 5.57485
R3826 VSS.n19 VSS.n17 5.57485
R3827 VSS.n223 VSS.n221 5.57485
R3828 VSS.n230 VSS.n229 5.57485
R3829 VSS.n237 VSS.n235 5.57485
R3830 VSS.n215 VSS.n214 5.57485
R3831 VSS.n210 VSS.n209 5.57485
R3832 VSS.n266 VSS.n264 5.57485
R3833 VSS.n256 VSS.n254 5.57485
R3834 VSS.n273 VSS.n272 5.57485
R3835 VSS.n278 VSS.n277 5.57485
R3836 VSS.n205 VSS.n204 5.52748
R3837 VSS.n282 VSS.n281 5.52748
R3838 VSS.n150 VSS.n149 5.48011
R3839 VSS.n174 VSS.n173 5.48011
R3840 VSS.n202 VSS.n201 5.48011
R3841 VSS.n58 VSS.n54 5.48011
R3842 VSS.n27 VSS.n23 5.48011
R3843 VSS.n6 VSS.n2 5.48011
R3844 VSS.n131 VSS.t439 5.46268
R3845 VSS.n1416 VSS.t103 5.46268
R3846 VSS.t278 VSS.t93 5.46268
R3847 VSS.t276 VSS.t458 5.46268
R3848 VSS.t547 VSS.t309 5.46268
R3849 VSS.t218 VSS.t211 5.46268
R3850 VSS.t216 VSS.t195 5.46268
R3851 VSS.t214 VSS.t386 5.46268
R3852 VSS.n1192 VSS.n432 5.46268
R3853 VSS.t289 VSS.t280 5.46268
R3854 VSS.n1229 VSS.t287 5.46268
R3855 VSS.n1248 VSS.t376 5.46268
R3856 VSS.n1165 VSS.t87 5.46268
R3857 VSS.n1162 VSS.t88 5.46268
R3858 VSS.n1131 VSS.t156 5.46268
R3859 VSS.t361 VSS.t34 5.46268
R3860 VSS.n1071 VSS.t504 5.46268
R3861 VSS.n1040 VSS.t121 5.46268
R3862 VSS.n1015 VSS.t485 5.46268
R3863 VSS.n543 VSS.t506 5.46268
R3864 VSS.n542 VSS.t391 5.46268
R3865 VSS.t178 VSS.t398 5.46268
R3866 VSS.t179 VSS.t406 5.46268
R3867 VSS.n981 VSS.t402 5.46268
R3868 VSS.n973 VSS.t415 5.46268
R3869 VSS.n952 VSS.t411 5.46268
R3870 VSS.t198 VSS.t549 5.46268
R3871 VSS.t196 VSS.t21 5.46268
R3872 VSS.t553 VSS.t200 5.46268
R3873 VSS.t496 VSS.t174 5.46268
R3874 VSS.t29 VSS.t172 5.46268
R3875 VSS.t469 VSS.t170 5.46268
R3876 VSS.n902 VSS.t359 5.46268
R3877 VSS.t347 VSS.n866 5.46268
R3878 VSS.n804 VSS.t394 5.46268
R3879 VSS.n772 VSS.t73 5.46268
R3880 VSS.n810 VSS.t112 5.46268
R3881 VSS.n148 VSS.n147 5.38537
R3882 VSS.n154 VSS.n153 5.38537
R3883 VSS.n156 VSS.n155 5.38537
R3884 VSS.n159 VSS.n158 5.38537
R3885 VSS.n163 VSS.n162 5.38537
R3886 VSS.n168 VSS.n167 5.38537
R3887 VSS.n177 VSS.n169 5.38537
R3888 VSS.n172 VSS.n171 5.38537
R3889 VSS.n179 VSS.n178 5.38537
R3890 VSS.n191 VSS.n190 5.38537
R3891 VSS.n193 VSS.n192 5.38537
R3892 VSS.n196 VSS.n195 5.38537
R3893 VSS.n200 VSS.n199 5.38537
R3894 VSS.n186 VSS.n185 5.38537
R3895 VSS.n57 VSS.n56 5.38537
R3896 VSS.n52 VSS.n45 5.38537
R3897 VSS.n50 VSS.n49 5.38537
R3898 VSS.n48 VSS.n47 5.38537
R3899 VSS.n42 VSS.n41 5.38537
R3900 VSS.n35 VSS.n22 5.38537
R3901 VSS.n26 VSS.n25 5.38537
R3902 VSS.n34 VSS.n33 5.38537
R3903 VSS.n32 VSS.n31 5.38537
R3904 VSS.n15 VSS.n8 5.38537
R3905 VSS.n13 VSS.n12 5.38537
R3906 VSS.n11 VSS.n10 5.38537
R3907 VSS.n5 VSS.n4 5.38537
R3908 VSS.n19 VSS.n18 5.38537
R3909 VSS.n220 VSS.n219 5.38537
R3910 VSS.n225 VSS.n224 5.38537
R3911 VSS.n223 VSS.n222 5.38537
R3912 VSS.n234 VSS.n233 5.38537
R3913 VSS.n239 VSS.n238 5.38537
R3914 VSS.n237 VSS.n236 5.38537
R3915 VSS.n215 VSS.n213 5.38537
R3916 VSS.n210 VSS.n208 5.38537
R3917 VSS.n263 VSS.n262 5.38537
R3918 VSS.n268 VSS.n267 5.38537
R3919 VSS.n266 VSS.n265 5.38537
R3920 VSS.n252 VSS.n251 5.38537
R3921 VSS.n249 VSS.n248 5.38537
R3922 VSS.n257 VSS.n253 5.38537
R3923 VSS.n256 VSS.n255 5.38537
R3924 VSS.n273 VSS.n271 5.38537
R3925 VSS.n278 VSS.n276 5.38537
R3926 VSS.n240 VSS.n232 5.28311
R3927 VSS.t374 VSS.n1164 5.28061
R3928 VSS.t446 VSS.n404 5.28061
R3929 VSS.n365 VSS.n364 5.2005
R3930 VSS.n362 VSS.n347 5.2005
R3931 VSS.n361 VSS.n351 5.2005
R3932 VSS.n359 VSS.n358 5.2005
R3933 VSS.n353 VSS.n352 5.2005
R3934 VSS.n357 VSS.n353 5.2005
R3935 VSS.n355 VSS.n313 5.2005
R3936 VSS.n356 VSS.n355 5.2005
R3937 VSS.n1344 VSS.n312 5.2005
R3938 VSS.n354 VSS.n312 5.2005
R3939 VSS.n1346 VSS.n1345 5.2005
R3940 VSS.n1346 VSS.n311 5.2005
R3941 VSS.n1348 VSS.n1347 5.2005
R3942 VSS.n1349 VSS.n1348 5.2005
R3943 VSS.n310 VSS.n309 5.2005
R3944 VSS.n1350 VSS.n310 5.2005
R3945 VSS.n1375 VSS.n1373 5.2005
R3946 VSS.n1373 VSS.n297 5.2005
R3947 VSS.n1372 VSS.n1371 5.2005
R3948 VSS.n1372 VSS.n299 5.2005
R3949 VSS.n1370 VSS.n298 5.2005
R3950 VSS.n302 VSS.n298 5.2005
R3951 VSS.n1369 VSS.n1368 5.2005
R3952 VSS.n1368 VSS.n1367 5.2005
R3953 VSS.n301 VSS.n300 5.2005
R3954 VSS.n1366 VSS.n301 5.2005
R3955 VSS.n1364 VSS.n1363 5.2005
R3956 VSS.n1365 VSS.n1364 5.2005
R3957 VSS.n1362 VSS.n304 5.2005
R3958 VSS.n304 VSS.n303 5.2005
R3959 VSS.n1361 VSS.n1360 5.2005
R3960 VSS.n1360 VSS.n1359 5.2005
R3961 VSS.n306 VSS.n305 5.2005
R3962 VSS.n1358 VSS.n306 5.2005
R3963 VSS.n1356 VSS.n1355 5.2005
R3964 VSS.n1357 VSS.n1356 5.2005
R3965 VSS.n1354 VSS.n308 5.2005
R3966 VSS.n308 VSS.n307 5.2005
R3967 VSS.n1353 VSS.n1352 5.2005
R3968 VSS.n1352 VSS.n1351 5.2005
R3969 VSS.n327 VSS.n326 5.2005
R3970 VSS.n325 VSS.n324 5.2005
R3971 VSS.n317 VSS.n316 5.2005
R3972 VSS.n1336 VSS.n1335 5.2005
R3973 VSS.n1337 VSS.n315 5.2005
R3974 VSS.n1339 VSS.n1338 5.2005
R3975 VSS.n294 VSS.n289 5.2005
R3976 VSS.n296 VSS.n294 5.2005
R3977 VSS.n1382 VSS.n1381 5.2005
R3978 VSS.n1381 VSS.n1380 5.2005
R3979 VSS.n1374 VSS.n295 5.2005
R3980 VSS.n1379 VSS.n295 5.2005
R3981 VSS.n1377 VSS.n1376 5.2005
R3982 VSS.n1378 VSS.n1377 5.2005
R3983 VSS.n349 VSS.n338 5.2005
R3984 VSS.n367 VSS.n338 5.2005
R3985 VSS.n370 VSS.n369 5.2005
R3986 VSS.n369 VSS.n368 5.2005
R3987 VSS.n337 VSS.t345 5.2005
R3988 VSS.n339 VSS.n337 5.2005
R3989 VSS.n373 VSS.n334 5.2005
R3990 VSS.n334 VSS.n333 5.2005
R3991 VSS.n377 VSS.n376 5.2005
R3992 VSS.n378 VSS.n377 5.2005
R3993 VSS.t310 VSS.n332 5.2005
R3994 VSS.n379 VSS.n332 5.2005
R3995 VSS.n382 VSS.n381 5.2005
R3996 VSS.n381 VSS.n380 5.2005
R3997 VSS.n385 VSS.n330 5.2005
R3998 VSS.n330 VSS.n329 5.2005
R3999 VSS.n1326 VSS.t118 5.2005
R4000 VSS.n1327 VSS.n1326 5.2005
R4001 VSS.n1323 VSS.n323 5.2005
R4002 VSS.n1328 VSS.n323 5.2005
R4003 VSS.n1331 VSS.n1330 5.2005
R4004 VSS.n1330 VSS.n1329 5.2005
R4005 VSS.n328 VSS.n321 5.2005
R4006 VSS.n1298 VSS.n319 5.2005
R4007 VSS.n1298 VSS.n1274 5.2005
R4008 VSS.n1297 VSS.n1275 5.2005
R4009 VSS.n1295 VSS.n1294 5.2005
R4010 VSS.n1293 VSS.n1276 5.2005
R4011 VSS.n1292 VSS.n1291 5.2005
R4012 VSS.n1290 VSS.n1277 5.2005
R4013 VSS.n1288 VSS.n1287 5.2005
R4014 VSS.n1286 VSS.n1279 5.2005
R4015 VSS.n1285 VSS.n1284 5.2005
R4016 VSS.n1300 VSS.n1299 5.2005
R4017 VSS.n1307 VSS.n1306 5.2005
R4018 VSS.n1309 VSS.n1308 5.2005
R4019 VSS.n1311 VSS.n1310 5.2005
R4020 VSS.n1313 VSS.n1312 5.2005
R4021 VSS.n1315 VSS.n1314 5.2005
R4022 VSS.n1316 VSS.n390 5.2005
R4023 VSS.n1318 VSS.n1317 5.2005
R4024 VSS.n1052 VSS.n509 5.2005
R4025 VSS.n1074 VSS.n509 5.2005
R4026 VSS.t34 VSS.n1076 5.2005
R4027 VSS.n1076 VSS.n1075 5.2005
R4028 VSS.n1229 VSS.n414 5.2005
R4029 VSS.n436 VSS.n414 5.2005
R4030 VSS.n1171 VSS.t167 5.2005
R4031 VSS.n1172 VSS.n1171 5.2005
R4032 VSS.n1223 VSS.n425 5.2005
R4033 VSS.n1173 VSS.n425 5.2005
R4034 VSS.n1174 VSS.n432 5.2005
R4035 VSS.n1175 VSS.n1174 5.2005
R4036 VSS.n1191 VSS.n433 5.2005
R4037 VSS.n1176 VSS.n433 5.2005
R4038 VSS.n1178 VSS.n1177 5.2005
R4039 VSS.n1179 VSS.n1178 5.2005
R4040 VSS.n1185 VSS.n435 5.2005
R4041 VSS.n1180 VSS.n435 5.2005
R4042 VSS.n1184 VSS.n1183 5.2005
R4043 VSS.n1183 VSS.n1182 5.2005
R4044 VSS.n1396 VSS.n143 5.2005
R4045 VSS.n1181 VSS.n143 5.2005
R4046 VSS.n144 VSS.n138 5.2005
R4047 VSS.n138 VSS.n137 5.2005
R4048 VSS.n1403 VSS.n1402 5.2005
R4049 VSS.n1404 VSS.n1403 5.2005
R4050 VSS.n139 VSS.n136 5.2005
R4051 VSS.n1405 VSS.n136 5.2005
R4052 VSS.n1409 VSS.n1407 5.2005
R4053 VSS.n1407 VSS.n1406 5.2005
R4054 VSS.n1408 VSS.n129 5.2005
R4055 VSS.n129 VSS.n128 5.2005
R4056 VSS.n1417 VSS.n1416 5.2005
R4057 VSS.n1418 VSS.n1417 5.2005
R4058 VSS.n131 VSS.n127 5.2005
R4059 VSS.n1419 VSS.n127 5.2005
R4060 VSS.n1421 VSS.n117 5.2005
R4061 VSS.n1421 VSS.n1420 5.2005
R4062 VSS.n1443 VSS.n1442 5.2005
R4063 VSS.n1442 VSS.n1441 5.2005
R4064 VSS.n1440 VSS.n124 5.2005
R4065 VSS.n1439 VSS.n1438 5.2005
R4066 VSS.n1437 VSS.n1436 5.2005
R4067 VSS.n1435 VSS.n1434 5.2005
R4068 VSS.n1433 VSS.n1432 5.2005
R4069 VSS.n1431 VSS.n1430 5.2005
R4070 VSS.n1429 VSS.n1428 5.2005
R4071 VSS.n1427 VSS.n1426 5.2005
R4072 VSS.n1425 VSS.n1424 5.2005
R4073 VSS.n1423 VSS.n1422 5.2005
R4074 VSS.n1072 VSS.n1071 5.2005
R4075 VSS.n1073 VSS.n1072 5.2005
R4076 VSS.n511 VSS.n510 5.2005
R4077 VSS.n1056 VSS.n1055 5.2005
R4078 VSS.n1071 VSS.n513 5.2005
R4079 VSS.n1057 VSS.n513 5.2005
R4080 VSS.n1059 VSS.n1058 5.2005
R4081 VSS.n1061 VSS.n1060 5.2005
R4082 VSS.n1063 VSS.n1062 5.2005
R4083 VSS.n1065 VSS.n1064 5.2005
R4084 VSS.n1071 VSS.n516 5.2005
R4085 VSS.n1066 VSS.n516 5.2005
R4086 VSS.n1067 VSS.n517 5.2005
R4087 VSS.n1069 VSS.n1068 5.2005
R4088 VSS.n1053 VSS.n1052 5.2005
R4089 VSS.n1054 VSS.n1053 5.2005
R4090 VSS.t34 VSS.n419 5.2005
R4091 VSS.n421 VSS.n419 5.2005
R4092 VSS.n1229 VSS.n1228 5.2005
R4093 VSS.n1228 VSS.n1227 5.2005
R4094 VSS.t167 VSS.n420 5.2005
R4095 VSS.n1226 VSS.n420 5.2005
R4096 VSS.n1224 VSS.n1223 5.2005
R4097 VSS.n1225 VSS.n1224 5.2005
R4098 VSS.n432 VSS.n423 5.2005
R4099 VSS.n423 VSS.n422 5.2005
R4100 VSS.n1191 VSS.n1190 5.2005
R4101 VSS.n1190 VSS.n1189 5.2005
R4102 VSS.n1177 VSS.n434 5.2005
R4103 VSS.n1188 VSS.n434 5.2005
R4104 VSS.n1186 VSS.n1185 5.2005
R4105 VSS.n1187 VSS.n1186 5.2005
R4106 VSS.n1184 VSS.n142 5.2005
R4107 VSS.n142 VSS.n141 5.2005
R4108 VSS.n1397 VSS.n1396 5.2005
R4109 VSS.n1398 VSS.n1397 5.2005
R4110 VSS.n144 VSS.n140 5.2005
R4111 VSS.n1399 VSS.n140 5.2005
R4112 VSS.n1402 VSS.n1401 5.2005
R4113 VSS.n1401 VSS.n1400 5.2005
R4114 VSS.n139 VSS.n134 5.2005
R4115 VSS.n134 VSS.n133 5.2005
R4116 VSS.n1410 VSS.n1409 5.2005
R4117 VSS.n1411 VSS.n1410 5.2005
R4118 VSS.n1408 VSS.n130 5.2005
R4119 VSS.n1412 VSS.n130 5.2005
R4120 VSS.n1416 VSS.n1415 5.2005
R4121 VSS.n1415 VSS.n1414 5.2005
R4122 VSS.n132 VSS.n131 5.2005
R4123 VSS.n1413 VSS.n132 5.2005
R4124 VSS.n123 VSS.n117 5.2005
R4125 VSS.n125 VSS.n123 5.2005
R4126 VSS.n896 VSS.n895 5.2005
R4127 VSS.n897 VSS.n896 5.2005
R4128 VSS.n866 VSS.n582 5.2005
R4129 VSS.n898 VSS.n582 5.2005
R4130 VSS.n902 VSS.n901 5.2005
R4131 VSS.n901 VSS.n900 5.2005
R4132 VSS.n583 VSS.n578 5.2005
R4133 VSS.n899 VSS.n583 5.2005
R4134 VSS.n908 VSS.n577 5.2005
R4135 VSS.n577 VSS.n576 5.2005
R4136 VSS.n910 VSS.n909 5.2005
R4137 VSS.n911 VSS.n910 5.2005
R4138 VSS.n922 VSS.n575 5.2005
R4139 VSS.n912 VSS.n575 5.2005
R4140 VSS.n921 VSS.n920 5.2005
R4141 VSS.n920 VSS.n919 5.2005
R4142 VSS.n928 VSS.n571 5.2005
R4143 VSS.n918 VSS.n571 5.2005
R4144 VSS.n916 VSS.n915 5.2005
R4145 VSS.n917 VSS.n916 5.2005
R4146 VSS.n932 VSS.n568 5.2005
R4147 VSS.n914 VSS.n568 5.2005
R4148 VSS.n569 VSS.n564 5.2005
R4149 VSS.n913 VSS.n564 5.2005
R4150 VSS.n939 VSS.n938 5.2005
R4151 VSS.n939 VSS.n563 5.2005
R4152 VSS.n940 VSS.n561 5.2005
R4153 VSS.n941 VSS.n940 5.2005
R4154 VSS.n946 VSS.n562 5.2005
R4155 VSS.n942 VSS.n562 5.2005
R4156 VSS.n945 VSS.n944 5.2005
R4157 VSS.n944 VSS.n943 5.2005
R4158 VSS.n952 VSS.n550 5.2005
R4159 VSS.n550 VSS.n549 5.2005
R4160 VSS.n982 VSS.n981 5.2005
R4161 VSS.n983 VSS.n982 5.2005
R4162 VSS.n1007 VSS.n537 5.2005
R4163 VSS.n984 VSS.n537 5.2005
R4164 VSS.n543 VSS.n539 5.2005
R4165 VSS.n1004 VSS.n539 5.2005
R4166 VSS.n1003 VSS.n1002 5.2005
R4167 VSS.n1000 VSS.n541 5.2005
R4168 VSS.n999 VSS.n544 5.2005
R4169 VSS.n997 VSS.n996 5.2005
R4170 VSS.n995 VSS.n545 5.2005
R4171 VSS.n994 VSS.n993 5.2005
R4172 VSS.n992 VSS.n546 5.2005
R4173 VSS.n990 VSS.n989 5.2005
R4174 VSS.n988 VSS.n548 5.2005
R4175 VSS.n987 VSS.n986 5.2005
R4176 VSS.n865 VSS.n585 5.2005
R4177 VSS.n873 VSS.n585 5.2005
R4178 VSS.n876 VSS.n875 5.2005
R4179 VSS.n877 VSS.n872 5.2005
R4180 VSS.n879 VSS.n878 5.2005
R4181 VSS.n881 VSS.n870 5.2005
R4182 VSS.n883 VSS.n882 5.2005
R4183 VSS.n884 VSS.n869 5.2005
R4184 VSS.n886 VSS.n885 5.2005
R4185 VSS.n888 VSS.n868 5.2005
R4186 VSS.n891 VSS.n890 5.2005
R4187 VSS.n892 VSS.n867 5.2005
R4188 VSS.n895 VSS.n894 5.2005
R4189 VSS.n894 VSS.n893 5.2005
R4190 VSS.n866 VSS.n581 5.2005
R4191 VSS.n581 VSS.n580 5.2005
R4192 VSS.n903 VSS.n902 5.2005
R4193 VSS.n904 VSS.n903 5.2005
R4194 VSS.n579 VSS.n578 5.2005
R4195 VSS.n905 VSS.n579 5.2005
R4196 VSS.n908 VSS.n907 5.2005
R4197 VSS.n907 VSS.n906 5.2005
R4198 VSS.n909 VSS.n574 5.2005
R4199 VSS.n574 VSS.n573 5.2005
R4200 VSS.n923 VSS.n922 5.2005
R4201 VSS.n924 VSS.n923 5.2005
R4202 VSS.n921 VSS.n572 5.2005
R4203 VSS.n925 VSS.n572 5.2005
R4204 VSS.n928 VSS.n927 5.2005
R4205 VSS.n927 VSS.n926 5.2005
R4206 VSS.n915 VSS.n567 5.2005
R4207 VSS.n567 VSS.n566 5.2005
R4208 VSS.n933 VSS.n932 5.2005
R4209 VSS.n934 VSS.n933 5.2005
R4210 VSS.n569 VSS.n565 5.2005
R4211 VSS.n935 VSS.n565 5.2005
R4212 VSS.n938 VSS.n937 5.2005
R4213 VSS.n937 VSS.n936 5.2005
R4214 VSS.n561 VSS.n560 5.2005
R4215 VSS.n560 VSS.n559 5.2005
R4216 VSS.n947 VSS.n946 5.2005
R4217 VSS.n948 VSS.n947 5.2005
R4218 VSS.n945 VSS.n558 5.2005
R4219 VSS.n949 VSS.n558 5.2005
R4220 VSS.n952 VSS.n951 5.2005
R4221 VSS.n951 VSS.n950 5.2005
R4222 VSS.n981 VSS.n538 5.2005
R4223 VSS.n540 VSS.n538 5.2005
R4224 VSS.n1007 VSS.n1006 5.2005
R4225 VSS.n1006 VSS.n1005 5.2005
R4226 VSS.n552 VSS.n551 5.2005
R4227 VSS.n977 VSS.n552 5.2005
R4228 VSS.t408 VSS.n980 5.2005
R4229 VSS.n980 VSS.n979 5.2005
R4230 VSS.n1009 VSS.n536 5.2005
R4231 VSS.n978 VSS.n536 5.2005
R4232 VSS.n542 VSS.n528 5.2005
R4233 VSS.n528 VSS.n527 5.2005
R4234 VSS.n1016 VSS.n1015 5.2005
R4235 VSS.n1017 VSS.n1016 5.2005
R4236 VSS.n529 VSS.n526 5.2005
R4237 VSS.n1018 VSS.n526 5.2005
R4238 VSS.n1023 VSS.n1021 5.2005
R4239 VSS.n1021 VSS.n1020 5.2005
R4240 VSS.n1022 VSS.n521 5.2005
R4241 VSS.n1019 VSS.n521 5.2005
R4242 VSS.n1033 VSS.n1032 5.2005
R4243 VSS.n1033 VSS.n520 5.2005
R4244 VSS.n1034 VSS.n394 5.2005
R4245 VSS.n1035 VSS.n1034 5.2005
R4246 VSS.n519 VSS.n395 5.2005
R4247 VSS.n1036 VSS.n519 5.2005
R4248 VSS.n1040 VSS.n1039 5.2005
R4249 VSS.n1039 VSS.n1038 5.2005
R4250 VSS.n1261 VSS.n397 5.2005
R4251 VSS.n1037 VSS.n397 5.2005
R4252 VSS.n472 VSS.n406 5.2005
R4253 VSS.n408 VSS.n406 5.2005
R4254 VSS.t448 VSS.n1255 5.2005
R4255 VSS.n1255 VSS.n1254 5.2005
R4256 VSS.t132 VSS.n407 5.2005
R4257 VSS.n1253 VSS.n407 5.2005
R4258 VSS.n1248 VSS.n1247 5.2005
R4259 VSS.n1247 VSS.n1246 5.2005
R4260 VSS.n1245 VSS.n1233 5.2005
R4261 VSS.n1244 VSS.n1243 5.2005
R4262 VSS.n1242 VSS.n1241 5.2005
R4263 VSS.n1240 VSS.n1239 5.2005
R4264 VSS.n1238 VSS.n1237 5.2005
R4265 VSS.n1236 VSS.n1235 5.2005
R4266 VSS.n1234 VSS.n413 5.2005
R4267 VSS.n1251 VSS.n1250 5.2005
R4268 VSS.n976 VSS.n975 5.2005
R4269 VSS.n959 VSS.n557 5.2005
R4270 VSS.n961 VSS.n960 5.2005
R4271 VSS.n963 VSS.n962 5.2005
R4272 VSS.n965 VSS.n964 5.2005
R4273 VSS.n967 VSS.n966 5.2005
R4274 VSS.n973 VSS.n955 5.2005
R4275 VSS.n968 VSS.n955 5.2005
R4276 VSS.n969 VSS.n956 5.2005
R4277 VSS.n971 VSS.n970 5.2005
R4278 VSS.n957 VSS.n551 5.2005
R4279 VSS.n958 VSS.n957 5.2005
R4280 VSS.t408 VSS.n534 5.2005
R4281 VSS.n534 VSS.n533 5.2005
R4282 VSS.n1010 VSS.n1009 5.2005
R4283 VSS.n1011 VSS.n1010 5.2005
R4284 VSS.n542 VSS.n532 5.2005
R4285 VSS.n1012 VSS.n532 5.2005
R4286 VSS.n1015 VSS.n1014 5.2005
R4287 VSS.n1014 VSS.n1013 5.2005
R4288 VSS.n529 VSS.n525 5.2005
R4289 VSS.n525 VSS.n524 5.2005
R4290 VSS.n1024 VSS.n1023 5.2005
R4291 VSS.n1025 VSS.n1024 5.2005
R4292 VSS.n1022 VSS.n522 5.2005
R4293 VSS.n1026 VSS.n522 5.2005
R4294 VSS.n1032 VSS.n1031 5.2005
R4295 VSS.n1031 VSS.n1030 5.2005
R4296 VSS.n523 VSS.n394 5.2005
R4297 VSS.n1029 VSS.n523 5.2005
R4298 VSS.n1027 VSS.n395 5.2005
R4299 VSS.n1028 VSS.n1027 5.2005
R4300 VSS.n1040 VSS.n399 5.2005
R4301 VSS.n401 VSS.n399 5.2005
R4302 VSS.n1261 VSS.n1260 5.2005
R4303 VSS.n1260 VSS.n1259 5.2005
R4304 VSS.n472 VSS.n400 5.2005
R4305 VSS.n1258 VSS.n400 5.2005
R4306 VSS.n1256 VSS.t448 5.2005
R4307 VSS.n1257 VSS.n1256 5.2005
R4308 VSS.t132 VSS.n403 5.2005
R4309 VSS.n403 VSS.n402 5.2005
R4310 VSS.n732 VSS.n610 5.2005
R4311 VSS.n610 VSS.n608 5.2005
R4312 VSS.n810 VSS.n745 5.2005
R4313 VSS.n768 VSS.n745 5.2005
R4314 VSS.n772 VSS.n771 5.2005
R4315 VSS.n771 VSS.n770 5.2005
R4316 VSS.n804 VSS.n600 5.2005
R4317 VSS.n769 VSS.n600 5.2005
R4318 VSS.n854 VSS.n853 5.2005
R4319 VSS.n854 VSS.n599 5.2005
R4320 VSS.n856 VSS.n586 5.2005
R4321 VSS.n857 VSS.n856 5.2005
R4322 VSS.n849 VSS.n848 5.2005
R4323 VSS.n847 VSS.n846 5.2005
R4324 VSS.n845 VSS.n844 5.2005
R4325 VSS.n843 VSS.n842 5.2005
R4326 VSS.n841 VSS.n840 5.2005
R4327 VSS.n839 VSS.n838 5.2005
R4328 VSS.n837 VSS.n836 5.2005
R4329 VSS.n855 VSS.n598 5.2005
R4330 VSS.n826 VSS.n825 5.2005
R4331 VSS.n827 VSS.n826 5.2005
R4332 VSS.n609 VSS.n607 5.2005
R4333 VSS.n815 VSS.n814 5.2005
R4334 VSS.n825 VSS.n738 5.2005
R4335 VSS.n816 VSS.n738 5.2005
R4336 VSS.n818 VSS.n817 5.2005
R4337 VSS.n820 VSS.n819 5.2005
R4338 VSS.n821 VSS.n740 5.2005
R4339 VSS.n823 VSS.n822 5.2005
R4340 VSS.n741 VSS.n732 5.2005
R4341 VSS.n813 VSS.n741 5.2005
R4342 VSS.n811 VSS.n810 5.2005
R4343 VSS.n812 VSS.n811 5.2005
R4344 VSS.n772 VSS.n743 5.2005
R4345 VSS.n743 VSS.n742 5.2005
R4346 VSS.n804 VSS.n604 5.2005
R4347 VSS.n606 VSS.n604 5.2005
R4348 VSS.n853 VSS.n852 5.2005
R4349 VSS.n852 VSS.n851 5.2005
R4350 VSS.n605 VSS.n586 5.2005
R4351 VSS.n850 VSS.n605 5.2005
R4352 VSS.n676 VSS.n675 5.2005
R4353 VSS.n677 VSS.n676 5.2005
R4354 VSS.n648 VSS.n642 5.2005
R4355 VSS.n678 VSS.n642 5.2005
R4356 VSS.n683 VSS.n680 5.2005
R4357 VSS.n680 VSS.n679 5.2005
R4358 VSS.n637 VSS.n636 5.2005
R4359 VSS.n636 VSS.n635 5.2005
R4360 VSS.n690 VSS.n689 5.2005
R4361 VSS.n691 VSS.n690 5.2005
R4362 VSS.n638 VSS.n634 5.2005
R4363 VSS.n692 VSS.n634 5.2005
R4364 VSS.n696 VSS.n694 5.2005
R4365 VSS.n694 VSS.n693 5.2005
R4366 VSS.n695 VSS.n626 5.2005
R4367 VSS.n626 VSS.n625 5.2005
R4368 VSS.n704 VSS.n703 5.2005
R4369 VSS.n705 VSS.n704 5.2005
R4370 VSS.n629 VSS.n624 5.2005
R4371 VSS.n706 VSS.n624 5.2005
R4372 VSS.n708 VSS.n611 5.2005
R4373 VSS.n708 VSS.n707 5.2005
R4374 VSS.n730 VSS.n729 5.2005
R4375 VSS.n729 VSS.n728 5.2005
R4376 VSS.n727 VSS.n617 5.2005
R4377 VSS.n726 VSS.n725 5.2005
R4378 VSS.n724 VSS.n723 5.2005
R4379 VSS.n722 VSS.n721 5.2005
R4380 VSS.n720 VSS.n719 5.2005
R4381 VSS.n718 VSS.n717 5.2005
R4382 VSS.n716 VSS.n715 5.2005
R4383 VSS.n710 VSS.n709 5.2005
R4384 VSS.n644 VSS.n643 5.2005
R4385 VSS.n655 VSS.n654 5.2005
R4386 VSS.n661 VSS.n660 5.2005
R4387 VSS.n663 VSS.n652 5.2005
R4388 VSS.n665 VSS.n664 5.2005
R4389 VSS.n667 VSS.n666 5.2005
R4390 VSS.n668 VSS.n645 5.2005
R4391 VSS.n668 VSS.n650 5.2005
R4392 VSS.n671 VSS.n670 5.2005
R4393 VSS.n672 VSS.n649 5.2005
R4394 VSS.n675 VSS.n674 5.2005
R4395 VSS.n674 VSS.n673 5.2005
R4396 VSS.n648 VSS.n641 5.2005
R4397 VSS.n641 VSS.n640 5.2005
R4398 VSS.n684 VSS.n683 5.2005
R4399 VSS.n685 VSS.n684 5.2005
R4400 VSS.n639 VSS.n637 5.2005
R4401 VSS.n686 VSS.n639 5.2005
R4402 VSS.n689 VSS.n688 5.2005
R4403 VSS.n688 VSS.n687 5.2005
R4404 VSS.n638 VSS.n632 5.2005
R4405 VSS.n632 VSS.n631 5.2005
R4406 VSS.n697 VSS.n696 5.2005
R4407 VSS.n698 VSS.n697 5.2005
R4408 VSS.n695 VSS.n628 5.2005
R4409 VSS.n699 VSS.n628 5.2005
R4410 VSS.n703 VSS.n702 5.2005
R4411 VSS.n702 VSS.n701 5.2005
R4412 VSS.n630 VSS.n629 5.2005
R4413 VSS.n700 VSS.n630 5.2005
R4414 VSS.n616 VSS.n611 5.2005
R4415 VSS.n618 VSS.n616 5.2005
R4416 VSS.n797 VSS.n732 5.2005
R4417 VSS.n798 VSS.n797 5.2005
R4418 VSS.n810 VSS.n746 5.2005
R4419 VSS.n799 VSS.n746 5.2005
R4420 VSS.n773 VSS.n772 5.2005
R4421 VSS.n800 VSS.n773 5.2005
R4422 VSS.n804 VSS.n803 5.2005
R4423 VSS.n803 VSS.n802 5.2005
R4424 VSS.n853 VSS.n602 5.2005
R4425 VSS.n801 VSS.n602 5.2005
R4426 VSS.n595 VSS.n586 5.2005
R4427 VSS.n597 VSS.n595 5.2005
R4428 VSS.n762 VSS.n761 5.2005
R4429 VSS.n760 VSS.n759 5.2005
R4430 VSS.n758 VSS.n757 5.2005
R4431 VSS.n756 VSS.n755 5.2005
R4432 VSS.n754 VSS.n753 5.2005
R4433 VSS.n752 VSS.n751 5.2005
R4434 VSS.n750 VSS.n594 5.2005
R4435 VSS.n862 VSS.n861 5.2005
R4436 VSS.n796 VSS.n795 5.2005
R4437 VSS.n787 VSS.n786 5.2005
R4438 VSS.n785 VSS.n784 5.2005
R4439 VSS.n783 VSS.n782 5.2005
R4440 VSS.n781 VSS.n780 5.2005
R4441 VSS.n779 VSS.n778 5.2005
R4442 VSS.n777 VSS.n776 5.2005
R4443 VSS.n775 VSS.n774 5.2005
R4444 VSS.n747 VSS.n732 5.2005
R4445 VSS.n749 VSS.n747 5.2005
R4446 VSS.n810 VSS.n809 5.2005
R4447 VSS.n809 VSS.n808 5.2005
R4448 VSS.n772 VSS.n748 5.2005
R4449 VSS.n807 VSS.n748 5.2005
R4450 VSS.n805 VSS.n804 5.2005
R4451 VSS.n806 VSS.n805 5.2005
R4452 VSS.n853 VSS.n603 5.2005
R4453 VSS.n765 VSS.n603 5.2005
R4454 VSS.n763 VSS.n586 5.2005
R4455 VSS.n764 VSS.n763 5.2005
R4456 VSS.t221 VSS.n1124 5.2005
R4457 VSS.n1124 VSS.n1123 5.2005
R4458 VSS.n1078 VSS.n465 5.2005
R4459 VSS.n465 VSS.n464 5.2005
R4460 VSS.n1132 VSS.n1131 5.2005
R4461 VSS.n1133 VSS.n1132 5.2005
R4462 VSS.n1162 VSS.n442 5.2005
R4463 VSS.n1134 VSS.n442 5.2005
R4464 VSS.n1229 VSS.n415 5.2005
R4465 VSS.n1135 VSS.n415 5.2005
R4466 VSS.n1156 VSS.n451 5.2005
R4467 VSS.n1136 VSS.n451 5.2005
R4468 VSS.n448 VSS.n447 5.2005
R4469 VSS.n1101 VSS.n1099 5.2005
R4470 VSS.n1104 VSS.n1103 5.2005
R4471 VSS.n1105 VSS.n1098 5.2005
R4472 VSS.n1107 VSS.n1106 5.2005
R4473 VSS.n1109 VSS.n1097 5.2005
R4474 VSS.n1113 VSS.n1112 5.2005
R4475 VSS.n1110 VSS.n463 5.2005
R4476 VSS.n1122 VSS.n474 5.2005
R4477 VSS.n1096 VSS.n1095 5.2005
R4478 VSS.n1093 VSS.n475 5.2005
R4479 VSS.n1091 VSS.n1090 5.2005
R4480 VSS.n1089 VSS.n476 5.2005
R4481 VSS.n1088 VSS.n1087 5.2005
R4482 VSS.n1085 VSS.n477 5.2005
R4483 VSS.n1083 VSS.n1082 5.2005
R4484 VSS.t221 VSS.n471 5.2005
R4485 VSS.n1081 VSS.n471 5.2005
R4486 VSS.n1079 VSS.n1078 5.2005
R4487 VSS.n1080 VSS.n1079 5.2005
R4488 VSS.n1131 VSS.n445 5.2005
R4489 VSS.n446 VSS.n445 5.2005
R4490 VSS.n1162 VSS.n1161 5.2005
R4491 VSS.n1161 VSS.n1160 5.2005
R4492 VSS.n1229 VSS.n418 5.2005
R4493 VSS.n1159 VSS.n418 5.2005
R4494 VSS.n1157 VSS.n1156 5.2005
R4495 VSS.n1158 VSS.n1157 5.2005
R4496 VSS.t221 VSS.n473 5.2005
R4497 VSS.n503 VSS.n473 5.2005
R4498 VSS.n1078 VSS.n508 5.2005
R4499 VSS.n508 VSS.n507 5.2005
R4500 VSS.n1131 VSS.n466 5.2005
R4501 VSS.n506 VSS.n466 5.2005
R4502 VSS.n1162 VSS.n443 5.2005
R4503 VSS.n505 VSS.n443 5.2005
R4504 VSS.n1229 VSS.n416 5.2005
R4505 VSS.n504 VSS.n416 5.2005
R4506 VSS.n1156 VSS.n452 5.2005
R4507 VSS.n462 VSS.n452 5.2005
R4508 VSS.n1153 VSS.n454 5.2005
R4509 VSS.n1152 VSS.n1151 5.2005
R4510 VSS.n1150 VSS.n456 5.2005
R4511 VSS.n1148 VSS.n1147 5.2005
R4512 VSS.n1146 VSS.n458 5.2005
R4513 VSS.n1145 VSS.n1144 5.2005
R4514 VSS.n1143 VSS.n459 5.2005
R4515 VSS.n1141 VSS.n1140 5.2005
R4516 VSS.n502 VSS.n501 5.2005
R4517 VSS.n499 VSS.n498 5.2005
R4518 VSS.n497 VSS.n485 5.2005
R4519 VSS.n496 VSS.n495 5.2005
R4520 VSS.n493 VSS.n486 5.2005
R4521 VSS.n491 VSS.n490 5.2005
R4522 VSS.n489 VSS.n488 5.2005
R4523 VSS.n469 VSS.n468 5.2005
R4524 VSS.n1125 VSS.t221 5.2005
R4525 VSS.n1126 VSS.n1125 5.2005
R4526 VSS.n1078 VSS.n467 5.2005
R4527 VSS.n1127 VSS.n467 5.2005
R4528 VSS.n1131 VSS.n1130 5.2005
R4529 VSS.n1130 VSS.n1129 5.2005
R4530 VSS.n1162 VSS.n444 5.2005
R4531 VSS.n1128 VSS.n444 5.2005
R4532 VSS.n1229 VSS.n417 5.2005
R4533 VSS.n455 VSS.n417 5.2005
R4534 VSS.n1156 VSS.n1155 5.2005
R4535 VSS.n1155 VSS.n1154 5.2005
R4536 VSS.n1218 VSS.n1217 5.2005
R4537 VSS.n1215 VSS.n430 5.2005
R4538 VSS.n1273 VSS.n391 5.2005
R4539 VSS.n1272 VSS.n1271 5.2005
R4540 VSS.n1268 VSS.n393 5.2005
R4541 VSS.n393 VSS.n392 5.2005
R4542 VSS.t191 VSS.n396 5.2005
R4543 VSS.n1047 VSS.n396 5.2005
R4544 VSS.n1041 VSS.t251 5.2005
R4545 VSS.n1048 VSS.n1041 5.2005
R4546 VSS.n1052 VSS.n1051 5.2005
R4547 VSS.n1051 VSS.n1050 5.2005
R4548 VSS.n1046 VSS.n1045 5.2005
R4549 VSS.n1049 VSS.n1046 5.2005
R4550 VSS.n1131 VSS.n441 5.2005
R4551 VSS.n441 VSS.n440 5.2005
R4552 VSS.n1166 VSS.n1165 5.2005
R4553 VSS.n1167 VSS.n1166 5.2005
R4554 VSS.n1156 VSS.n439 5.2005
R4555 VSS.n1168 VSS.n439 5.2005
R4556 VSS.t167 VSS.n1170 5.2005
R4557 VSS.n1170 VSS.n1169 5.2005
R4558 VSS.n437 VSS.n427 5.2005
R4559 VSS.n429 VSS.n427 5.2005
R4560 VSS.n1222 VSS.n1221 5.2005
R4561 VSS.n1221 VSS.n1220 5.2005
R4562 VSS.n431 VSS.n428 5.2005
R4563 VSS.n1219 VSS.n428 5.2005
R4564 VSS.n1214 VSS.n1213 5.2005
R4565 VSS.n1212 VSS.n1211 5.2005
R4566 VSS.n1210 VSS.n1209 5.2005
R4567 VSS.n1204 VSS.n1203 5.2005
R4568 VSS.n1202 VSS.n1201 5.2005
R4569 VSS.n1200 VSS.n1199 5.2005
R4570 VSS.n1198 VSS.n288 5.2005
R4571 VSS.n1385 VSS.n285 5.2005
R4572 VSS.n1283 VSS.n314 5.2005
R4573 VSS.n1283 VSS.n1280 5.2005
R4574 VSS.n1282 VSS.n286 5.2005
R4575 VSS.n1387 VSS.n1386 5.2005
R4576 VSS.n1465 VSS.n113 5.2005
R4577 VSS.n113 VSS.n112 5.2005
R4578 VSS.n1467 VSS.n1466 5.2005
R4579 VSS.n1468 VSS.n1467 5.2005
R4580 VSS.n114 VSS.n111 5.2005
R4581 VSS.n1469 VSS.n111 5.2005
R4582 VSS.n1472 VSS.n1471 5.2005
R4583 VSS.n1471 VSS.n1470 5.2005
R4584 VSS.n110 VSS.n100 5.2005
R4585 VSS.n100 VSS.n99 5.2005
R4586 VSS.n1478 VSS.t266 5.2005
R4587 VSS.n1479 VSS.n1478 5.2005
R4588 VSS.n101 VSS.n98 5.2005
R4589 VSS.n1480 VSS.n98 5.2005
R4590 VSS.n1483 VSS.n1482 5.2005
R4591 VSS.n1482 VSS.n1481 5.2005
R4592 VSS.n1487 VSS.n92 5.2005
R4593 VSS.n92 VSS.n91 5.2005
R4594 VSS.n1489 VSS.n1488 5.2005
R4595 VSS.n1490 VSS.n1489 5.2005
R4596 VSS.n94 VSS.n90 5.2005
R4597 VSS.n1491 VSS.n90 5.2005
R4598 VSS.n1494 VSS.n1493 5.2005
R4599 VSS.n1493 VSS.n1492 5.2005
R4600 VSS.n89 VSS.n79 5.2005
R4601 VSS.n79 VSS.n78 5.2005
R4602 VSS.n1500 VSS.t40 5.2005
R4603 VSS.n1501 VSS.n1500 5.2005
R4604 VSS.n80 VSS.n77 5.2005
R4605 VSS.n1502 VSS.n77 5.2005
R4606 VSS.n1505 VSS.n1504 5.2005
R4607 VSS.n1504 VSS.n1503 5.2005
R4608 VSS.n1506 VSS.n73 5.2005
R4609 VSS.n73 VSS.n72 5.2005
R4610 VSS.n1508 VSS.n1507 5.2005
R4611 VSS.n1509 VSS.n1508 5.2005
R4612 VSS.n71 VSS.n68 5.2005
R4613 VSS.n1510 VSS.n71 5.2005
R4614 VSS.n68 VSS.n64 5.2005
R4615 VSS.n64 VSS.n62 5.2005
R4616 VSS.n1507 VSS.n74 5.2005
R4617 VSS.n83 VSS.n74 5.2005
R4618 VSS.n1506 VSS.n75 5.2005
R4619 VSS.n84 VSS.n75 5.2005
R4620 VSS.n1505 VSS.n76 5.2005
R4621 VSS.n85 VSS.n76 5.2005
R4622 VSS.n81 VSS.n80 5.2005
R4623 VSS.n86 VSS.n81 5.2005
R4624 VSS.t40 VSS.n1499 5.2005
R4625 VSS.n1499 VSS.n1498 5.2005
R4626 VSS.n89 VSS.n82 5.2005
R4627 VSS.n1497 VSS.n82 5.2005
R4628 VSS.n1495 VSS.n1494 5.2005
R4629 VSS.n1496 VSS.n1495 5.2005
R4630 VSS.n94 VSS.n88 5.2005
R4631 VSS.n88 VSS.n87 5.2005
R4632 VSS.n1488 VSS.n95 5.2005
R4633 VSS.n104 VSS.n95 5.2005
R4634 VSS.n1487 VSS.n96 5.2005
R4635 VSS.n105 VSS.n96 5.2005
R4636 VSS.n1483 VSS.n97 5.2005
R4637 VSS.n106 VSS.n97 5.2005
R4638 VSS.n102 VSS.n101 5.2005
R4639 VSS.n107 VSS.n102 5.2005
R4640 VSS.t266 VSS.n1477 5.2005
R4641 VSS.n1477 VSS.n1476 5.2005
R4642 VSS.n110 VSS.n103 5.2005
R4643 VSS.n1475 VSS.n103 5.2005
R4644 VSS.n1473 VSS.n1472 5.2005
R4645 VSS.n1474 VSS.n1473 5.2005
R4646 VSS.n114 VSS.n109 5.2005
R4647 VSS.n109 VSS.n108 5.2005
R4648 VSS.n1466 VSS.n115 5.2005
R4649 VSS.n1449 VSS.n115 5.2005
R4650 VSS.n1465 VSS.n116 5.2005
R4651 VSS.n1450 VSS.n116 5.2005
R4652 VSS.n1464 VSS.n1463 5.2005
R4653 VSS.n1463 VSS.n1462 5.2005
R4654 VSS.n1461 VSS.n1448 5.2005
R4655 VSS.n1460 VSS.n1459 5.2005
R4656 VSS.n1458 VSS.n1457 5.2005
R4657 VSS.n1456 VSS.n1455 5.2005
R4658 VSS.n1454 VSS.n1453 5.2005
R4659 VSS.n1452 VSS.n1451 5.2005
R4660 VSS.n1523 VSS.n1522 5.2005
R4661 VSS.n65 VSS.n63 5.2005
R4662 VSS.n1512 VSS.n1511 5.2005
R4663 VSS.n1514 VSS.n1513 5.2005
R4664 VSS.n1520 VSS.n69 5.2005
R4665 VSS.n1515 VSS.n69 5.2005
R4666 VSS.n1516 VSS.n70 5.2005
R4667 VSS.n1518 VSS.n1517 5.2005
R4668 VSS.n1390 VSS.n1389 5.03058
R4669 VSS.n426 VSS.t165 4.95782
R4670 VSS.n1527 VSS.n1526 4.9505
R4671 VSS.n1528 VSS.n0 4.86439
R4672 VSS.t229 VSS.n450 4.73439
R4673 VSS.t158 VSS.n405 4.73439
R4674 VSS.n346 VSS.n345 4.7005
R4675 VSS.n1527 VSS.n1 4.67813
R4676 VSS.n124 VSS.n122 4.6486
R4677 VSS.n1437 VSS.n121 4.6486
R4678 VSS.n1433 VSS.n120 4.6486
R4679 VSS.n1429 VSS.n119 4.6486
R4680 VSS.n1425 VSS.n118 4.6486
R4681 VSS.n1055 VSS.n514 4.6486
R4682 VSS.n1058 VSS.n512 4.6486
R4683 VSS.n1064 VSS.n515 4.6486
R4684 VSS.n1002 VSS.n1001 4.6486
R4685 VSS.n999 VSS.n998 4.6486
R4686 VSS.n547 VSS.n545 4.6486
R4687 VSS.n992 VSS.n991 4.6486
R4688 VSS.n985 VSS.n548 4.6486
R4689 VSS.n875 VSS.n874 4.6486
R4690 VSS.n880 VSS.n879 4.6486
R4691 VSS.n871 VSS.n869 4.6486
R4692 VSS.n888 VSS.n887 4.6486
R4693 VSS.n1448 VSS.n1447 4.6486
R4694 VSS.n1458 VSS.n1446 4.6486
R4695 VSS.n1454 VSS.n1445 4.6486
R4696 VSS.n1522 VSS.n1521 4.6486
R4697 VSS.n1511 VSS.n67 4.6486
R4698 VSS.n1521 VSS.n65 4.6486
R4699 VSS.n1513 VSS.n67 4.6486
R4700 VSS.n1451 VSS.n1445 4.6486
R4701 VSS.n1455 VSS.n1446 4.6486
R4702 VSS.n1459 VSS.n1447 4.6486
R4703 VSS.n874 VSS.n872 4.6486
R4704 VSS.n881 VSS.n880 4.6486
R4705 VSS.n882 VSS.n871 4.6486
R4706 VSS.n887 VSS.n886 4.6486
R4707 VSS.n986 VSS.n985 4.6486
R4708 VSS.n991 VSS.n990 4.6486
R4709 VSS.n993 VSS.n547 4.6486
R4710 VSS.n998 VSS.n997 4.6486
R4711 VSS.n1001 VSS.n1000 4.6486
R4712 VSS.n514 VSS.n511 4.6486
R4713 VSS.n1061 VSS.n512 4.6486
R4714 VSS.n1062 VSS.n515 4.6486
R4715 VSS.n1422 VSS.n118 4.6486
R4716 VSS.n1426 VSS.n119 4.6486
R4717 VSS.n1430 VSS.n120 4.6486
R4718 VSS.n1434 VSS.n121 4.6486
R4719 VSS.n1438 VSS.n122 4.6486
R4720 VSS.n252 VSS.n250 4.59524
R4721 VSS.n1118 VSS.n1115 4.5005
R4722 VSS.n1120 VSS.n1119 4.5005
R4723 VSS.n481 VSS.n478 4.5005
R4724 VSS.n483 VSS.n482 4.5005
R4725 VSS.n1393 VSS.n1392 4.5005
R4726 VSS.n177 VSS.n176 4.5005
R4727 VSS.n175 VSS.n174 4.5005
R4728 VSS.n570 VSS.n60 4.5005
R4729 VSS.n34 VSS.n29 4.5005
R4730 VSS.n28 VSS.n27 4.5005
R4731 VSS.n791 VSS.n788 4.5005
R4732 VSS.n793 VSS.n792 4.5005
R4733 VSS.n834 VSS.n833 4.5005
R4734 VSS.n831 VSS.n829 4.5005
R4735 VSS.n226 VSS.n225 4.5005
R4736 VSS.n240 VSS.n239 4.5005
R4737 VSS.n211 VSS.n210 4.5005
R4738 VSS.n269 VSS.n268 4.5005
R4739 VSS.n258 VSS.n257 4.5005
R4740 VSS.n279 VSS.n278 4.5005
R4741 VSS.n1394 VSS.n1393 4.49787
R4742 VSS.n930 VSS.n570 4.49787
R4743 VSS.n375 VSS.n374 4.48215
R4744 VSS.n335 VSS.n331 4.48215
R4745 VSS.n384 VSS.n383 4.48215
R4746 VSS.n1325 VSS.n1324 4.48215
R4747 VSS.n1321 VSS.n322 4.48215
R4748 VSS.n364 VSS.n363 4.34122
R4749 VSS.n361 VSS.n360 4.34122
R4750 VSS.n326 VSS.n320 4.34122
R4751 VSS.n1334 VSS.n317 4.34122
R4752 VSS.n1340 VSS.n315 4.34122
R4753 VSS.n360 VSS.n359 4.34122
R4754 VSS.n363 VSS.n362 4.34122
R4755 VSS.n1340 VSS.n1339 4.34122
R4756 VSS.n1335 VSS.n1334 4.34122
R4757 VSS.n324 VSS.n320 4.34122
R4758 VSS.n1297 VSS.n1296 4.34122
R4759 VSS.n1278 VSS.n1276 4.34122
R4760 VSS.n1290 VSS.n1289 4.34122
R4761 VSS.n1281 VSS.n1279 4.34122
R4762 VSS.n1299 VSS.n387 4.34122
R4763 VSS.n1308 VSS.n388 4.34122
R4764 VSS.n1312 VSS.n389 4.34122
R4765 VSS.n1319 VSS.n390 4.34122
R4766 VSS.n1233 VSS.n1232 4.34122
R4767 VSS.n1242 VSS.n1231 4.34122
R4768 VSS.n1238 VSS.n1230 4.34122
R4769 VSS.n1249 VSS.n413 4.34122
R4770 VSS.n975 VSS.n974 4.34122
R4771 VSS.n963 VSS.n954 4.34122
R4772 VSS.n964 VSS.n953 4.34122
R4773 VSS.n972 VSS.n956 4.34122
R4774 VSS.n848 VSS.n587 4.34122
R4775 VSS.n845 VSS.n588 4.34122
R4776 VSS.n841 VSS.n589 4.34122
R4777 VSS.n837 VSS.n590 4.34122
R4778 VSS.n814 VSS.n737 4.34122
R4779 VSS.n817 VSS.n739 4.34122
R4780 VSS.n824 VSS.n740 4.34122
R4781 VSS.n617 VSS.n615 4.34122
R4782 VSS.n724 VSS.n614 4.34122
R4783 VSS.n720 VSS.n613 4.34122
R4784 VSS.n716 VSS.n612 4.34122
R4785 VSS.n653 VSS.n644 4.34122
R4786 VSS.n662 VSS.n661 4.34122
R4787 VSS.n664 VSS.n651 4.34122
R4788 VSS.n670 VSS.n669 4.34122
R4789 VSS.n762 VSS.n591 4.34122
R4790 VSS.n758 VSS.n592 4.34122
R4791 VSS.n754 VSS.n593 4.34122
R4792 VSS.n863 VSS.n594 4.34122
R4793 VSS.n796 VSS.n733 4.34122
R4794 VSS.n785 VSS.n734 4.34122
R4795 VSS.n781 VSS.n735 4.34122
R4796 VSS.n777 VSS.n736 4.34122
R4797 VSS.n1100 VSS.n448 4.34122
R4798 VSS.n1103 VSS.n1102 4.34122
R4799 VSS.n1108 VSS.n1107 4.34122
R4800 VSS.n1112 VSS.n1111 4.34122
R4801 VSS.n1094 VSS.n474 4.34122
R4802 VSS.n1093 VSS.n1092 4.34122
R4803 VSS.n1086 VSS.n476 4.34122
R4804 VSS.n1085 VSS.n1084 4.34122
R4805 VSS.n457 VSS.n454 4.34122
R4806 VSS.n1150 VSS.n1149 4.34122
R4807 VSS.n460 VSS.n458 4.34122
R4808 VSS.n1143 VSS.n1142 4.34122
R4809 VSS.n501 VSS.n500 4.34122
R4810 VSS.n494 VSS.n485 4.34122
R4811 VSS.n493 VSS.n492 4.34122
R4812 VSS.n488 VSS.n487 4.34122
R4813 VSS.n1217 VSS.n1216 4.34122
R4814 VSS.n1270 VSS.n391 4.34122
R4815 VSS.n1214 VSS.n290 4.34122
R4816 VSS.n1210 VSS.n291 4.34122
R4817 VSS.n1202 VSS.n292 4.34122
R4818 VSS.n1384 VSS.n288 4.34122
R4819 VSS.n1282 VSS.n287 4.34122
R4820 VSS.n1386 VSS.n287 4.34122
R4821 VSS.n1284 VSS.n1281 4.34122
R4822 VSS.n1289 VSS.n1288 4.34122
R4823 VSS.n1291 VSS.n1278 4.34122
R4824 VSS.n1296 VSS.n1295 4.34122
R4825 VSS.n1385 VSS.n1384 4.34122
R4826 VSS.n1199 VSS.n292 4.34122
R4827 VSS.n1203 VSS.n291 4.34122
R4828 VSS.n1211 VSS.n290 4.34122
R4829 VSS.n1216 VSS.n1215 4.34122
R4830 VSS.n1307 VSS.n387 4.34122
R4831 VSS.n1311 VSS.n388 4.34122
R4832 VSS.n1314 VSS.n389 4.34122
R4833 VSS.n1319 VSS.n1318 4.34122
R4834 VSS.n1271 VSS.n1270 4.34122
R4835 VSS.n500 VSS.n499 4.34122
R4836 VSS.n495 VSS.n494 4.34122
R4837 VSS.n492 VSS.n491 4.34122
R4838 VSS.n487 VSS.n469 4.34122
R4839 VSS.n1142 VSS.n1141 4.34122
R4840 VSS.n1144 VSS.n460 4.34122
R4841 VSS.n1149 VSS.n1148 4.34122
R4842 VSS.n1151 VSS.n457 4.34122
R4843 VSS.n1095 VSS.n1094 4.34122
R4844 VSS.n1092 VSS.n1091 4.34122
R4845 VSS.n1087 VSS.n1086 4.34122
R4846 VSS.n1084 VSS.n1083 4.34122
R4847 VSS.n1111 VSS.n1110 4.34122
R4848 VSS.n1109 VSS.n1108 4.34122
R4849 VSS.n1102 VSS.n1098 4.34122
R4850 VSS.n1101 VSS.n1100 4.34122
R4851 VSS.n786 VSS.n733 4.34122
R4852 VSS.n782 VSS.n734 4.34122
R4853 VSS.n778 VSS.n735 4.34122
R4854 VSS.n774 VSS.n736 4.34122
R4855 VSS.n863 VSS.n862 4.34122
R4856 VSS.n751 VSS.n593 4.34122
R4857 VSS.n755 VSS.n592 4.34122
R4858 VSS.n759 VSS.n591 4.34122
R4859 VSS.n654 VSS.n653 4.34122
R4860 VSS.n663 VSS.n662 4.34122
R4861 VSS.n667 VSS.n651 4.34122
R4862 VSS.n669 VSS.n649 4.34122
R4863 VSS.n709 VSS.n612 4.34122
R4864 VSS.n717 VSS.n613 4.34122
R4865 VSS.n721 VSS.n614 4.34122
R4866 VSS.n725 VSS.n615 4.34122
R4867 VSS.n737 VSS.n609 4.34122
R4868 VSS.n819 VSS.n739 4.34122
R4869 VSS.n824 VSS.n823 4.34122
R4870 VSS.n855 VSS.n590 4.34122
R4871 VSS.n838 VSS.n589 4.34122
R4872 VSS.n842 VSS.n588 4.34122
R4873 VSS.n846 VSS.n587 4.34122
R4874 VSS.n974 VSS.n557 4.34122
R4875 VSS.n960 VSS.n954 4.34122
R4876 VSS.n966 VSS.n953 4.34122
R4877 VSS.n972 VSS.n971 4.34122
R4878 VSS.n1250 VSS.n1249 4.34122
R4879 VSS.n1235 VSS.n1230 4.34122
R4880 VSS.n1239 VSS.n1231 4.34122
R4881 VSS.n1243 VSS.n1232 4.34122
R4882 VSS.n1519 VSS.n70 4.20229
R4883 VSS.n1519 VSS.n1518 4.20229
R4884 VSS.n1267 VSS.n1266 4.08867
R4885 VSS.n1077 VSS.n405 4.08867
R4886 VSS.n450 VSS.n449 4.08867
R4887 VSS.n164 VSS.n160 3.83734
R4888 VSS.n20 VSS.n16 3.83734
R4889 VSS.n1070 VSS.n517 3.72542
R4890 VSS.n890 VSS.n889 3.72542
R4891 VSS.n889 VSS.n867 3.72542
R4892 VSS.n1070 VSS.n1069 3.72542
R4893 VSS.n348 VSS.n336 3.6553
R4894 VSS.n372 VSS.n371 3.6553
R4895 VSS.n1402 VSS.t450 3.64196
R4896 VSS.n1402 VSS.t9 3.64196
R4897 VSS.n1191 VSS.t210 3.64196
R4898 VSS.t181 VSS.n1191 3.64196
R4899 VSS.t132 VSS.t87 3.64196
R4900 VSS.t88 VSS.t132 3.64196
R4901 VSS.t222 VSS.t361 3.64196
R4902 VSS.n1078 VSS.t10 3.64196
R4903 VSS.t472 VSS.t97 3.64196
R4904 VSS.n1052 VSS.t150 3.64196
R4905 VSS.n1261 VSS.n398 3.64196
R4906 VSS.n1268 VSS.t176 3.64196
R4907 VSS.t177 VSS.n1268 3.64196
R4908 VSS.n1269 VSS.n394 3.64196
R4909 VSS.n1007 VSS.t391 3.64196
R4910 VSS.t392 VSS.n1007 3.64196
R4911 VSS.n938 VSS.t164 3.64196
R4912 VSS.n938 VSS.t131 3.64196
R4913 VSS.n922 VSS.t455 3.64196
R4914 VSS.n922 VSS.t138 3.64196
R4915 VSS.t26 VSS.t393 3.64196
R4916 VSS.t394 VSS.t26 3.64196
R4917 VSS.t111 VSS.t488 3.64196
R4918 VSS.t488 VSS.t112 3.64196
R4919 VSS.n629 VSS.t30 3.64196
R4920 VSS.n629 VSS.t31 3.64196
R4921 VSS.n695 VSS.t3 3.64196
R4922 VSS.t5 VSS.n695 3.64196
R4923 VSS.n638 VSS.t473 3.64196
R4924 VSS.t474 VSS.n638 3.64196
R4925 VSS.t101 VSS.t91 3.64196
R4926 VSS.t91 VSS.t102 3.64196
R4927 VSS.n683 VSS.t143 3.64196
R4928 VSS.n683 VSS.t145 3.64196
R4929 VSS.t428 VSS.t27 3.64196
R4930 VSS.t27 VSS.t443 3.64196
R4931 VSS.n1263 VSS.n1262 3.63551
R4932 VSS.n518 VSS.n470 3.63551
R4933 VSS.n703 VSS.n627 3.62054
R4934 VSS.n696 VSS.n633 3.62054
R4935 VSS.n1223 VSS.n424 3.56721
R4936 VSS.n437 VSS.n424 3.56721
R4937 VSS.n1008 VSS.n535 3.54389
R4938 VSS.n531 VSS.n530 3.54389
R4939 VSS.n1265 VSS.n1264 3.54389
R4940 VSS.n1043 VSS.n1042 3.54389
R4941 VSS.n647 VSS.n646 3.49549
R4942 VSS.n682 VSS.n681 3.49549
R4943 VSS.n1044 VSS.t11 3.45988
R4944 VSS.n165 VSS.n164 3.43471
R4945 VSS.n21 VSS.n20 3.43471
R4946 VSS.t176 VSS.n1267 2.91367
R4947 VSS.n176 VSS.n175 2.73963
R4948 VSS.n29 VSS.n28 2.73963
R4949 VSS.n450 VSS.t293 2.54952
R4950 VSS.t448 VSS.n405 2.54952
R4951 VSS.n1077 VSS.t222 2.54952
R4952 VSS.n1266 VSS.n395 2.54952
R4953 VSS.n1164 VSS.t376 2.0033
R4954 VSS.t448 VSS.n404 2.0033
R4955 VSS.t281 VSS.n1044 2.0033
R4956 VSS.n1045 VSS.n1043 2.0033
R4957 VSS.t221 VSS.n470 2.0033
R4958 VSS.n1042 VSS.t472 2.0033
R4959 VSS.n1052 VSS.n518 2.0033
R4960 VSS.n1264 VSS.t471 2.0033
R4961 VSS.n681 VSS.n637 2.0033
R4962 VSS.n648 VSS.n647 2.0033
R4963 VSS.n131 VSS.t437 1.82123
R4964 VSS.n1416 VSS.t105 1.82123
R4965 VSS.t458 VSS.t278 1.82123
R4966 VSS.t309 VSS.t276 1.82123
R4967 VSS.n144 VSS.t382 1.82123
R4968 VSS.n1177 VSS.t381 1.82123
R4969 VSS.t211 VSS.t216 1.82123
R4970 VSS.t195 VSS.t214 1.82123
R4971 VSS.n1156 VSS.t229 1.82123
R4972 VSS.t280 VSS.t291 1.82123
R4973 VSS.t378 VSS.n1229 1.82123
R4974 VSS.n1248 VSS.t378 1.82123
R4975 VSS.n1165 VSS.t374 1.82123
R4976 VSS.n1131 VSS.t158 1.82123
R4977 VSS.t34 VSS.t446 1.82123
R4978 VSS.t10 VSS.t285 1.82123
R4979 VSS.n1078 VSS.t283 1.82123
R4980 VSS.t11 VSS.t283 1.82123
R4981 VSS.t150 VSS.n398 1.82123
R4982 VSS.n1071 VSS.t502 1.82123
R4983 VSS.n543 VSS.t508 1.82123
R4984 VSS.t406 VSS.t178 1.82123
R4985 VSS.t404 VSS.t179 1.82123
R4986 VSS.n981 VSS.t400 1.82123
R4987 VSS.n973 VSS.t413 1.82123
R4988 VSS.t413 VSS.n952 1.82123
R4989 VSS.t21 VSS.t198 1.82123
R4990 VSS.t200 VSS.t196 1.82123
R4991 VSS.n569 VSS.t303 1.82123
R4992 VSS.t550 VSS.n921 1.82123
R4993 VSS.t172 VSS.t496 1.82123
R4994 VSS.t170 VSS.t29 1.82123
R4995 VSS.n902 VSS.t357 1.82123
R4996 VSS.n866 VSS.t349 1.82123
R4997 VSS.n772 VSS.t77 1.82123
R4998 VSS.n767 VSS.n744 1.79498
R4999 VSS.n766 VSS.n601 1.79498
R5000 VSS.n1044 VSS.n404 1.75086
R5001 VSS.n1164 VSS.n1163 1.75086
R5002 VSS.n1042 VSS.t96 1.63916
R5003 VSS.t149 VSS.n518 1.63916
R5004 VSS.n1262 VSS.t502 1.63916
R5005 VSS.n1263 VSS.t121 1.63916
R5006 VSS.t135 VSS.n1265 1.63916
R5007 VSS.n531 VSS.t136 1.63916
R5008 VSS.t99 VSS.n1008 1.63916
R5009 VSS.n187 VSS.n183 1.3505
R5010 VSS.n43 VSS.n39 1.3505
R5011 VSS.n203 VSS.n197 1.23208
R5012 VSS.n183 VSS.n180 1.23208
R5013 VSS.n39 VSS.n36 1.23208
R5014 VSS.n59 VSS.n53 1.23208
R5015 VSS.n1420 VSS.n1419 1.1255
R5016 VSS.n1419 VSS.n1418 1.1255
R5017 VSS.n1418 VSS.n128 1.1255
R5018 VSS.n1406 VSS.n128 1.1255
R5019 VSS.n1406 VSS.n1405 1.1255
R5020 VSS.n1405 VSS.n1404 1.1255
R5021 VSS.n1404 VSS.n137 1.1255
R5022 VSS.n1181 VSS.n137 1.1255
R5023 VSS.n1182 VSS.n1181 1.1255
R5024 VSS.n1182 VSS.n1180 1.1255
R5025 VSS.n1180 VSS.n1179 1.1255
R5026 VSS.n1179 VSS.n1176 1.1255
R5027 VSS.n1176 VSS.n1175 1.1255
R5028 VSS.n1175 VSS.n1173 1.1255
R5029 VSS.n1173 VSS.n1172 1.1255
R5030 VSS.n1172 VSS.n436 1.1255
R5031 VSS.n1075 VSS.n436 1.1255
R5032 VSS.n1075 VSS.n1074 1.1255
R5033 VSS.n1073 VSS.n510 1.1255
R5034 VSS.n1056 VSS.n510 1.1255
R5035 VSS.n1057 VSS.n1056 1.1255
R5036 VSS.n1059 VSS.n1057 1.1255
R5037 VSS.n1060 VSS.n1059 1.1255
R5038 VSS.n1063 VSS.n1060 1.1255
R5039 VSS.n1065 VSS.n1063 1.1255
R5040 VSS.n1066 VSS.n1065 1.1255
R5041 VSS.n1067 VSS.n1066 1.1255
R5042 VSS.n1413 VSS.n125 1.1255
R5043 VSS.n1414 VSS.n1413 1.1255
R5044 VSS.n1414 VSS.n1412 1.1255
R5045 VSS.n1412 VSS.n1411 1.1255
R5046 VSS.n1411 VSS.n133 1.1255
R5047 VSS.n1400 VSS.n133 1.1255
R5048 VSS.n1400 VSS.n1399 1.1255
R5049 VSS.n1399 VSS.n1398 1.1255
R5050 VSS.n1398 VSS.n141 1.1255
R5051 VSS.n1187 VSS.n141 1.1255
R5052 VSS.n1188 VSS.n1187 1.1255
R5053 VSS.n1189 VSS.n1188 1.1255
R5054 VSS.n1189 VSS.n422 1.1255
R5055 VSS.n1225 VSS.n422 1.1255
R5056 VSS.n1226 VSS.n1225 1.1255
R5057 VSS.n1227 VSS.n1226 1.1255
R5058 VSS.n1227 VSS.n421 1.1255
R5059 VSS.n1054 VSS.n421 1.1255
R5060 VSS.n1424 VSS.n1423 1.1255
R5061 VSS.n1427 VSS.n1424 1.1255
R5062 VSS.n1428 VSS.n1427 1.1255
R5063 VSS.n1431 VSS.n1428 1.1255
R5064 VSS.n1432 VSS.n1431 1.1255
R5065 VSS.n1435 VSS.n1432 1.1255
R5066 VSS.n1436 VSS.n1435 1.1255
R5067 VSS.n1439 VSS.n1436 1.1255
R5068 VSS.n1440 VSS.n1439 1.1255
R5069 VSS.n984 VSS.n983 1.1255
R5070 VSS.n983 VSS.n549 1.1255
R5071 VSS.n943 VSS.n549 1.1255
R5072 VSS.n943 VSS.n942 1.1255
R5073 VSS.n942 VSS.n941 1.1255
R5074 VSS.n941 VSS.n563 1.1255
R5075 VSS.n913 VSS.n563 1.1255
R5076 VSS.n914 VSS.n913 1.1255
R5077 VSS.n917 VSS.n914 1.1255
R5078 VSS.n918 VSS.n917 1.1255
R5079 VSS.n919 VSS.n918 1.1255
R5080 VSS.n919 VSS.n912 1.1255
R5081 VSS.n912 VSS.n911 1.1255
R5082 VSS.n911 VSS.n576 1.1255
R5083 VSS.n899 VSS.n576 1.1255
R5084 VSS.n900 VSS.n899 1.1255
R5085 VSS.n900 VSS.n898 1.1255
R5086 VSS.n898 VSS.n897 1.1255
R5087 VSS.n988 VSS.n987 1.1255
R5088 VSS.n989 VSS.n988 1.1255
R5089 VSS.n989 VSS.n546 1.1255
R5090 VSS.n994 VSS.n546 1.1255
R5091 VSS.n995 VSS.n994 1.1255
R5092 VSS.n996 VSS.n995 1.1255
R5093 VSS.n996 VSS.n544 1.1255
R5094 VSS.n544 VSS.n541 1.1255
R5095 VSS.n1003 VSS.n541 1.1255
R5096 VSS.n1005 VSS.n540 1.1255
R5097 VSS.n950 VSS.n540 1.1255
R5098 VSS.n950 VSS.n949 1.1255
R5099 VSS.n949 VSS.n948 1.1255
R5100 VSS.n948 VSS.n559 1.1255
R5101 VSS.n936 VSS.n559 1.1255
R5102 VSS.n936 VSS.n935 1.1255
R5103 VSS.n935 VSS.n934 1.1255
R5104 VSS.n934 VSS.n566 1.1255
R5105 VSS.n926 VSS.n566 1.1255
R5106 VSS.n926 VSS.n925 1.1255
R5107 VSS.n925 VSS.n924 1.1255
R5108 VSS.n924 VSS.n573 1.1255
R5109 VSS.n906 VSS.n573 1.1255
R5110 VSS.n906 VSS.n905 1.1255
R5111 VSS.n905 VSS.n904 1.1255
R5112 VSS.n904 VSS.n580 1.1255
R5113 VSS.n893 VSS.n580 1.1255
R5114 VSS.n876 VSS.n873 1.1255
R5115 VSS.n877 VSS.n876 1.1255
R5116 VSS.n878 VSS.n877 1.1255
R5117 VSS.n878 VSS.n870 1.1255
R5118 VSS.n883 VSS.n870 1.1255
R5119 VSS.n884 VSS.n883 1.1255
R5120 VSS.n885 VSS.n884 1.1255
R5121 VSS.n885 VSS.n868 1.1255
R5122 VSS.n891 VSS.n868 1.1255
R5123 VSS.n1523 VSS.n63 1.1255
R5124 VSS.n1512 VSS.n63 1.1255
R5125 VSS.n1514 VSS.n1512 1.1255
R5126 VSS.n1515 VSS.n1514 1.1255
R5127 VSS.n1516 VSS.n1515 1.1255
R5128 VSS.n1450 VSS.n1449 1.1255
R5129 VSS.n1449 VSS.n108 1.1255
R5130 VSS.n1474 VSS.n108 1.1255
R5131 VSS.n1475 VSS.n1474 1.1255
R5132 VSS.n1476 VSS.n1475 1.1255
R5133 VSS.n1476 VSS.n107 1.1255
R5134 VSS.n107 VSS.n106 1.1255
R5135 VSS.n106 VSS.n105 1.1255
R5136 VSS.n105 VSS.n104 1.1255
R5137 VSS.n104 VSS.n87 1.1255
R5138 VSS.n1496 VSS.n87 1.1255
R5139 VSS.n1497 VSS.n1496 1.1255
R5140 VSS.n1498 VSS.n1497 1.1255
R5141 VSS.n1498 VSS.n86 1.1255
R5142 VSS.n86 VSS.n85 1.1255
R5143 VSS.n85 VSS.n84 1.1255
R5144 VSS.n84 VSS.n83 1.1255
R5145 VSS.n83 VSS.n62 1.1255
R5146 VSS.n1453 VSS.n1452 1.1255
R5147 VSS.n1456 VSS.n1453 1.1255
R5148 VSS.n1457 VSS.n1456 1.1255
R5149 VSS.n1460 VSS.n1457 1.1255
R5150 VSS.n1461 VSS.n1460 1.1255
R5151 VSS.n1468 VSS.n112 1.1255
R5152 VSS.n1469 VSS.n1468 1.1255
R5153 VSS.n1470 VSS.n1469 1.1255
R5154 VSS.n1470 VSS.n99 1.1255
R5155 VSS.n1479 VSS.n99 1.1255
R5156 VSS.n1480 VSS.n1479 1.1255
R5157 VSS.n1481 VSS.n1480 1.1255
R5158 VSS.n1481 VSS.n91 1.1255
R5159 VSS.n1490 VSS.n91 1.1255
R5160 VSS.n1491 VSS.n1490 1.1255
R5161 VSS.n1492 VSS.n1491 1.1255
R5162 VSS.n1492 VSS.n78 1.1255
R5163 VSS.n1501 VSS.n78 1.1255
R5164 VSS.n1502 VSS.n1501 1.1255
R5165 VSS.n1503 VSS.n1502 1.1255
R5166 VSS.n1503 VSS.n72 1.1255
R5167 VSS.n1509 VSS.n72 1.1255
R5168 VSS.n1510 VSS.n1509 1.1255
R5169 VSS.n449 VSS.t287 1.09294
R5170 VSS.t285 VSS.n1077 1.09294
R5171 VSS.n1389 VSS.n284 0.994742
R5172 VSS.n1138 VSS.n284 0.991003
R5173 VSS.n1378 VSS.n297 0.9905
R5174 VSS.n345 VSS.n344 0.9005
R5175 VSS.n344 VSS.n343 0.9005
R5176 VSS.n343 VSS.n342 0.9005
R5177 VSS.n342 VSS.n341 0.9005
R5178 VSS.n341 VSS.n340 0.9005
R5179 VSS.n328 VSS.n327 0.878
R5180 VSS.n1074 VSS.n1073 0.878
R5181 VSS.n987 VSS.n984 0.878
R5182 VSS.n1452 VSS.n1450 0.878
R5183 VSS.n1205 VSS.t319 0.8195
R5184 VSS.n1205 VSS.t320 0.8195
R5185 VSS.n1206 VSS.t314 0.8195
R5186 VSS.n1206 VSS.t315 0.8195
R5187 VSS.n1351 VSS.n1350 0.7655
R5188 VSS.n1272 VSS.n392 0.7655
R5189 VSS.n1219 VSS.n1218 0.7655
R5190 VSS.n1123 VSS.n1122 0.7655
R5191 VSS.n503 VSS.n502 0.7655
R5192 VSS.n798 VSS.n795 0.7655
R5193 VSS.n827 VSS.n608 0.7655
R5194 VSS.n1071 VSS.n1070 0.73879
R5195 VSS.n889 VSS.n865 0.73879
R5196 VSS.n1526 VSS.n60 0.698
R5197 VSS.n1350 VSS.n1349 0.6755
R5198 VSS.n1349 VSS.n311 0.6755
R5199 VSS.n354 VSS.n311 0.6755
R5200 VSS.n356 VSS.n354 0.6755
R5201 VSS.n357 VSS.n356 0.6755
R5202 VSS.n358 VSS.n357 0.6755
R5203 VSS.n358 VSS.n351 0.6755
R5204 VSS.n351 VSS.n347 0.6755
R5205 VSS.n365 VSS.n347 0.6755
R5206 VSS.n1351 VSS.n307 0.6755
R5207 VSS.n1357 VSS.n307 0.6755
R5208 VSS.n1358 VSS.n1357 0.6755
R5209 VSS.n1359 VSS.n1358 0.6755
R5210 VSS.n1359 VSS.n303 0.6755
R5211 VSS.n1365 VSS.n303 0.6755
R5212 VSS.n1366 VSS.n1365 0.6755
R5213 VSS.n1367 VSS.n1366 0.6755
R5214 VSS.n1367 VSS.n302 0.6755
R5215 VSS.n302 VSS.n299 0.6755
R5216 VSS.n299 VSS.n297 0.6755
R5217 VSS.n1379 VSS.n1378 0.6755
R5218 VSS.n1380 VSS.n1379 0.6755
R5219 VSS.n1380 VSS.n296 0.6755
R5220 VSS.n1338 VSS.n296 0.6755
R5221 VSS.n1338 VSS.n1337 0.6755
R5222 VSS.n1337 VSS.n1336 0.6755
R5223 VSS.n1336 VSS.n316 0.6755
R5224 VSS.n325 VSS.n316 0.6755
R5225 VSS.n327 VSS.n325 0.6755
R5226 VSS.n368 VSS.n367 0.6755
R5227 VSS.n368 VSS.n339 0.6755
R5228 VSS.n339 VSS.n333 0.6755
R5229 VSS.n378 VSS.n333 0.6755
R5230 VSS.n379 VSS.n378 0.6755
R5231 VSS.n380 VSS.n379 0.6755
R5232 VSS.n380 VSS.n329 0.6755
R5233 VSS.n1327 VSS.n329 0.6755
R5234 VSS.n1328 VSS.n1327 0.6755
R5235 VSS.n1329 VSS.n1328 0.6755
R5236 VSS.n1329 VSS.n328 0.6755
R5237 VSS.n1387 VSS.n286 0.6755
R5238 VSS.n1280 VSS.n286 0.6755
R5239 VSS.n1285 VSS.n1280 0.6755
R5240 VSS.n1286 VSS.n1285 0.6755
R5241 VSS.n1287 VSS.n1286 0.6755
R5242 VSS.n1287 VSS.n1277 0.6755
R5243 VSS.n1292 VSS.n1277 0.6755
R5244 VSS.n1293 VSS.n1292 0.6755
R5245 VSS.n1294 VSS.n1293 0.6755
R5246 VSS.n1294 VSS.n1275 0.6755
R5247 VSS.n1309 VSS.n1306 0.6755
R5248 VSS.n1310 VSS.n1309 0.6755
R5249 VSS.n1313 VSS.n1310 0.6755
R5250 VSS.n1315 VSS.n1313 0.6755
R5251 VSS.n1316 VSS.n1315 0.6755
R5252 VSS.n1317 VSS.n1316 0.6755
R5253 VSS.n1317 VSS.n1273 0.6755
R5254 VSS.n1273 VSS.n1272 0.6755
R5255 VSS.n1220 VSS.n1219 0.6755
R5256 VSS.n1220 VSS.n429 0.6755
R5257 VSS.n1169 VSS.n429 0.6755
R5258 VSS.n1169 VSS.n1168 0.6755
R5259 VSS.n1168 VSS.n1167 0.6755
R5260 VSS.n1167 VSS.n440 0.6755
R5261 VSS.n1049 VSS.n440 0.6755
R5262 VSS.n1050 VSS.n1049 0.6755
R5263 VSS.n1050 VSS.n1048 0.6755
R5264 VSS.n1048 VSS.n1047 0.6755
R5265 VSS.n1200 VSS.n1198 0.6755
R5266 VSS.n1201 VSS.n1200 0.6755
R5267 VSS.n1204 VSS.n1201 0.6755
R5268 VSS.n1212 VSS.n1209 0.6755
R5269 VSS.n1213 VSS.n1212 0.6755
R5270 VSS.n1213 VSS.n430 0.6755
R5271 VSS.n1218 VSS.n430 0.6755
R5272 VSS.n1113 VSS.n1097 0.6755
R5273 VSS.n1106 VSS.n1097 0.6755
R5274 VSS.n1106 VSS.n1105 0.6755
R5275 VSS.n1105 VSS.n1104 0.6755
R5276 VSS.n1104 VSS.n1099 0.6755
R5277 VSS.n1099 VSS.n447 0.6755
R5278 VSS.n1096 VSS.n475 0.6755
R5279 VSS.n1090 VSS.n475 0.6755
R5280 VSS.n1090 VSS.n1089 0.6755
R5281 VSS.n1089 VSS.n1088 0.6755
R5282 VSS.n1088 VSS.n477 0.6755
R5283 VSS.n1082 VSS.n477 0.6755
R5284 VSS.n1145 VSS.n459 0.6755
R5285 VSS.n1146 VSS.n1145 0.6755
R5286 VSS.n1147 VSS.n1146 0.6755
R5287 VSS.n1147 VSS.n456 0.6755
R5288 VSS.n1152 VSS.n456 0.6755
R5289 VSS.n1153 VSS.n1152 0.6755
R5290 VSS.n498 VSS.n497 0.6755
R5291 VSS.n497 VSS.n496 0.6755
R5292 VSS.n496 VSS.n486 0.6755
R5293 VSS.n490 VSS.n486 0.6755
R5294 VSS.n490 VSS.n489 0.6755
R5295 VSS.n489 VSS.n468 0.6755
R5296 VSS.n1236 VSS.n1234 0.6755
R5297 VSS.n1237 VSS.n1236 0.6755
R5298 VSS.n1240 VSS.n1237 0.6755
R5299 VSS.n1241 VSS.n1240 0.6755
R5300 VSS.n1244 VSS.n1241 0.6755
R5301 VSS.n1245 VSS.n1244 0.6755
R5302 VSS.n1246 VSS.n1245 0.6755
R5303 VSS.n1257 VSS.n402 0.6755
R5304 VSS.n1258 VSS.n1257 0.6755
R5305 VSS.n1259 VSS.n1258 0.6755
R5306 VSS.n1259 VSS.n401 0.6755
R5307 VSS.n1028 VSS.n401 0.6755
R5308 VSS.n1029 VSS.n1028 0.6755
R5309 VSS.n1030 VSS.n1029 0.6755
R5310 VSS.n1030 VSS.n1026 0.6755
R5311 VSS.n1026 VSS.n1025 0.6755
R5312 VSS.n1025 VSS.n524 0.6755
R5313 VSS.n1013 VSS.n524 0.6755
R5314 VSS.n1013 VSS.n1012 0.6755
R5315 VSS.n1012 VSS.n1011 0.6755
R5316 VSS.n1011 VSS.n533 0.6755
R5317 VSS.n958 VSS.n533 0.6755
R5318 VSS.n961 VSS.n959 0.6755
R5319 VSS.n962 VSS.n961 0.6755
R5320 VSS.n965 VSS.n962 0.6755
R5321 VSS.n967 VSS.n965 0.6755
R5322 VSS.n968 VSS.n967 0.6755
R5323 VSS.n969 VSS.n968 0.6755
R5324 VSS.n970 VSS.n969 0.6755
R5325 VSS.n1254 VSS.n1253 0.6755
R5326 VSS.n1254 VSS.n408 0.6755
R5327 VSS.n1037 VSS.n408 0.6755
R5328 VSS.n1038 VSS.n1037 0.6755
R5329 VSS.n1038 VSS.n1036 0.6755
R5330 VSS.n1036 VSS.n1035 0.6755
R5331 VSS.n1035 VSS.n520 0.6755
R5332 VSS.n1019 VSS.n520 0.6755
R5333 VSS.n1020 VSS.n1019 0.6755
R5334 VSS.n1020 VSS.n1018 0.6755
R5335 VSS.n1018 VSS.n1017 0.6755
R5336 VSS.n1017 VSS.n527 0.6755
R5337 VSS.n978 VSS.n527 0.6755
R5338 VSS.n979 VSS.n978 0.6755
R5339 VSS.n979 VSS.n977 0.6755
R5340 VSS.n752 VSS.n750 0.6755
R5341 VSS.n753 VSS.n752 0.6755
R5342 VSS.n756 VSS.n753 0.6755
R5343 VSS.n757 VSS.n756 0.6755
R5344 VSS.n760 VSS.n757 0.6755
R5345 VSS.n761 VSS.n760 0.6755
R5346 VSS.n787 VSS.n784 0.6755
R5347 VSS.n784 VSS.n783 0.6755
R5348 VSS.n783 VSS.n780 0.6755
R5349 VSS.n780 VSS.n779 0.6755
R5350 VSS.n779 VSS.n776 0.6755
R5351 VSS.n776 VSS.n775 0.6755
R5352 VSS.n839 VSS.n836 0.6755
R5353 VSS.n840 VSS.n839 0.6755
R5354 VSS.n843 VSS.n840 0.6755
R5355 VSS.n844 VSS.n843 0.6755
R5356 VSS.n847 VSS.n844 0.6755
R5357 VSS.n849 VSS.n847 0.6755
R5358 VSS.n815 VSS.n607 0.6755
R5359 VSS.n816 VSS.n815 0.6755
R5360 VSS.n818 VSS.n816 0.6755
R5361 VSS.n820 VSS.n818 0.6755
R5362 VSS.n821 VSS.n820 0.6755
R5363 VSS.n822 VSS.n821 0.6755
R5364 VSS.n719 VSS.n718 0.6755
R5365 VSS.n722 VSS.n719 0.6755
R5366 VSS.n723 VSS.n722 0.6755
R5367 VSS.n726 VSS.n723 0.6755
R5368 VSS.n727 VSS.n726 0.6755
R5369 VSS.n728 VSS.n727 0.6755
R5370 VSS.n700 VSS.n618 0.6755
R5371 VSS.n701 VSS.n700 0.6755
R5372 VSS.n701 VSS.n699 0.6755
R5373 VSS.n699 VSS.n698 0.6755
R5374 VSS.n698 VSS.n631 0.6755
R5375 VSS.n687 VSS.n631 0.6755
R5376 VSS.n687 VSS.n686 0.6755
R5377 VSS.n686 VSS.n685 0.6755
R5378 VSS.n685 VSS.n640 0.6755
R5379 VSS.n673 VSS.n640 0.6755
R5380 VSS.n655 VSS.n643 0.6755
R5381 VSS.n660 VSS.n652 0.6755
R5382 VSS.n665 VSS.n652 0.6755
R5383 VSS.n666 VSS.n665 0.6755
R5384 VSS.n666 VSS.n650 0.6755
R5385 VSS.n671 VSS.n650 0.6755
R5386 VSS.n672 VSS.n671 0.6755
R5387 VSS.n707 VSS.n706 0.6755
R5388 VSS.n706 VSS.n705 0.6755
R5389 VSS.n705 VSS.n625 0.6755
R5390 VSS.n693 VSS.n625 0.6755
R5391 VSS.n693 VSS.n692 0.6755
R5392 VSS.n692 VSS.n691 0.6755
R5393 VSS.n691 VSS.n635 0.6755
R5394 VSS.n679 VSS.n635 0.6755
R5395 VSS.n679 VSS.n678 0.6755
R5396 VSS.n678 VSS.n677 0.6755
R5397 VSS.n1300 VSS.n1274 0.653
R5398 VSS.n977 VSS.n976 0.653
R5399 VSS.n1068 VSS.n1054 0.653
R5400 VSS.n1441 VSS.n125 0.653
R5401 VSS.n1005 VSS.n1004 0.653
R5402 VSS.n893 VSS.n892 0.653
R5403 VSS.n728 VSS.n618 0.653
R5404 VSS.n1462 VSS.n112 0.653
R5405 VSS.n1517 VSS.n1510 0.653
R5406 VSS.n1392 VSS.n1391 0.6305
R5407 VSS.n715 VSS.n622 0.61925
R5408 VSS.n1234 VSS.n412 0.563
R5409 VSS.n959 VSS.n556 0.563
R5410 VSS.n1517 VSS.n1516 0.563
R5411 VSS.n1462 VSS.n1461 0.563
R5412 VSS.n1082 VSS.n1081 0.5405
R5413 VSS.n1126 VSS.n468 0.5405
R5414 VSS.n1246 VSS.n402 0.5405
R5415 VSS.n970 VSS.n958 0.5405
R5416 VSS.n245 VSS.n243 0.5405
R5417 VSS.n775 VSS.n749 0.5405
R5418 VSS.n822 VSS.n813 0.5405
R5419 VSS.n673 VSS.n672 0.5405
R5420 VSS.n677 VSS.n643 0.5405
R5421 VSS.n1420 VSS.n126 0.518
R5422 VSS.n897 VSS.n584 0.518
R5423 VSS.n1524 VSS.n62 0.518
R5424 VSS.n715 VSS.n714 0.50675
R5425 VSS.n1520 VSS.n1519 0.500354
R5426 VSS.n366 VSS.n365 0.47417
R5427 VSS.n1275 VSS.n1274 0.4505
R5428 VSS.n1306 VSS.n1305 0.4505
R5429 VSS.n1047 VSS.n392 0.4505
R5430 VSS.n1198 VSS.n1197 0.4505
R5431 VSS.n1159 VSS.n1158 0.4505
R5432 VSS.n1160 VSS.n1159 0.4505
R5433 VSS.n1160 VSS.n446 0.4505
R5434 VSS.n1080 VSS.n446 0.4505
R5435 VSS.n1081 VSS.n1080 0.4505
R5436 VSS.n1136 VSS.n1135 0.4505
R5437 VSS.n1135 VSS.n1134 0.4505
R5438 VSS.n1134 VSS.n1133 0.4505
R5439 VSS.n1133 VSS.n464 0.4505
R5440 VSS.n1123 VSS.n464 0.4505
R5441 VSS.n1154 VSS.n455 0.4505
R5442 VSS.n1128 VSS.n455 0.4505
R5443 VSS.n1129 VSS.n1128 0.4505
R5444 VSS.n1129 VSS.n1127 0.4505
R5445 VSS.n1127 VSS.n1126 0.4505
R5446 VSS.n504 VSS.n462 0.4505
R5447 VSS.n505 VSS.n504 0.4505
R5448 VSS.n506 VSS.n505 0.4505
R5449 VSS.n507 VSS.n506 0.4505
R5450 VSS.n507 VSS.n503 0.4505
R5451 VSS.n765 VSS.n764 0.4505
R5452 VSS.n806 VSS.n765 0.4505
R5453 VSS.n807 VSS.n806 0.4505
R5454 VSS.n808 VSS.n807 0.4505
R5455 VSS.n808 VSS.n749 0.4505
R5456 VSS.n801 VSS.n597 0.4505
R5457 VSS.n802 VSS.n801 0.4505
R5458 VSS.n802 VSS.n800 0.4505
R5459 VSS.n800 VSS.n799 0.4505
R5460 VSS.n799 VSS.n798 0.4505
R5461 VSS.n851 VSS.n850 0.4505
R5462 VSS.n851 VSS.n606 0.4505
R5463 VSS.n742 VSS.n606 0.4505
R5464 VSS.n812 VSS.n742 0.4505
R5465 VSS.n813 VSS.n812 0.4505
R5466 VSS.n857 VSS.n599 0.4505
R5467 VSS.n769 VSS.n599 0.4505
R5468 VSS.n770 VSS.n769 0.4505
R5469 VSS.n770 VSS.n768 0.4505
R5470 VSS.n768 VSS.n608 0.4505
R5471 VSS.n363 VSS.n350 0.430889
R5472 VSS.n360 VSS.n350 0.430889
R5473 VSS.n1333 VSS.n320 0.430889
R5474 VSS.n1334 VSS.n1333 0.430889
R5475 VSS.n1341 VSS.n1340 0.430889
R5476 VSS.n1296 VSS.n319 0.430889
R5477 VSS.n1278 VSS.n319 0.430889
R5478 VSS.n1289 VSS.n319 0.430889
R5479 VSS.n1281 VSS.n319 0.430889
R5480 VSS.n1320 VSS.n387 0.430889
R5481 VSS.n1320 VSS.n388 0.430889
R5482 VSS.n1320 VSS.n389 0.430889
R5483 VSS.n1320 VSS.n1319 0.430889
R5484 VSS.n1248 VSS.n1232 0.430889
R5485 VSS.n1248 VSS.n1231 0.430889
R5486 VSS.n1248 VSS.n1230 0.430889
R5487 VSS.n1249 VSS.n1248 0.430889
R5488 VSS.n974 VSS.n973 0.430889
R5489 VSS.n973 VSS.n954 0.430889
R5490 VSS.n973 VSS.n953 0.430889
R5491 VSS.n973 VSS.n972 0.430889
R5492 VSS.n864 VSS.n587 0.430889
R5493 VSS.n864 VSS.n588 0.430889
R5494 VSS.n864 VSS.n589 0.430889
R5495 VSS.n864 VSS.n590 0.430889
R5496 VSS.n825 VSS.n737 0.430889
R5497 VSS.n825 VSS.n739 0.430889
R5498 VSS.n825 VSS.n824 0.430889
R5499 VSS.n730 VSS.n615 0.430889
R5500 VSS.n730 VSS.n614 0.430889
R5501 VSS.n730 VSS.n613 0.430889
R5502 VSS.n730 VSS.n612 0.430889
R5503 VSS.n653 VSS.n645 0.430889
R5504 VSS.n662 VSS.n645 0.430889
R5505 VSS.n651 VSS.n645 0.430889
R5506 VSS.n669 VSS.n645 0.430889
R5507 VSS.n864 VSS.n591 0.430889
R5508 VSS.n864 VSS.n592 0.430889
R5509 VSS.n864 VSS.n593 0.430889
R5510 VSS.n864 VSS.n863 0.430889
R5511 VSS.n825 VSS.n733 0.430889
R5512 VSS.n825 VSS.n734 0.430889
R5513 VSS.n825 VSS.n735 0.430889
R5514 VSS.n825 VSS.n736 0.430889
R5515 VSS.n1100 VSS.n453 0.430889
R5516 VSS.n1102 VSS.n453 0.430889
R5517 VSS.n1108 VSS.n453 0.430889
R5518 VSS.n1111 VSS.n453 0.430889
R5519 VSS.n1094 VSS.n398 0.430889
R5520 VSS.n1092 VSS.n398 0.430889
R5521 VSS.n1086 VSS.n398 0.430889
R5522 VSS.n1084 VSS.n398 0.430889
R5523 VSS.n457 VSS.n453 0.430889
R5524 VSS.n1149 VSS.n453 0.430889
R5525 VSS.n460 VSS.n453 0.430889
R5526 VSS.n1142 VSS.n453 0.430889
R5527 VSS.n500 VSS.n398 0.430889
R5528 VSS.n494 VSS.n398 0.430889
R5529 VSS.n492 VSS.n398 0.430889
R5530 VSS.n487 VSS.n398 0.430889
R5531 VSS.n1216 VSS.n1192 0.430889
R5532 VSS.n1270 VSS.n1269 0.430889
R5533 VSS.n1383 VSS.n290 0.430889
R5534 VSS.n1383 VSS.n291 0.430889
R5535 VSS.n1383 VSS.n292 0.430889
R5536 VSS.n1384 VSS.n1383 0.430889
R5537 VSS.n314 VSS.n287 0.430889
R5538 VSS.n207 VSS.t487 0.41
R5539 VSS.n207 VSS.t486 0.41
R5540 VSS.n242 VSS.t372 0.41
R5541 VSS.n242 VSS.t189 0.41
R5542 VSS.n244 VSS.t226 0.41
R5543 VSS.n244 VSS.t224 0.41
R5544 VSS.n275 VSS.t463 0.41
R5545 VSS.n275 VSS.t461 0.41
R5546 VSS.n243 VSS.n241 0.3875
R5547 VSS.n1392 VSS.n203 0.379447
R5548 VSS.n60 VSS.n59 0.379447
R5549 VSS.n1388 VSS.n1387 0.37175
R5550 VSS.n1137 VSS.n1136 0.37175
R5551 VSS.n1139 VSS.n462 0.37175
R5552 VSS.n1253 VSS.n1252 0.37175
R5553 VSS.n860 VSS.n597 0.37175
R5554 VSS.n858 VSS.n857 0.37175
R5555 VSS.n707 VSS.n623 0.37175
R5556 VSS.n246 VSS.n245 0.3695
R5557 VSS.n1114 VSS.n463 0.366125
R5558 VSS.n1122 VSS.n1121 0.366125
R5559 VSS.n1140 VSS.n461 0.366125
R5560 VSS.n502 VSS.n484 0.366125
R5561 VSS.n861 VSS.n596 0.366125
R5562 VSS.n795 VSS.n794 0.366125
R5563 VSS.n835 VSS.n598 0.366125
R5564 VSS.n828 VSS.n827 0.366125
R5565 VSS.n1208 VSS.n1204 0.3605
R5566 VSS.n1423 VSS.n126 0.3605
R5567 VSS.n873 VSS.n584 0.3605
R5568 VSS.n1524 VSS.n1523 0.3605
R5569 VSS.n1068 VSS.n1067 0.338
R5570 VSS.n1441 VSS.n1440 0.338
R5571 VSS.n1004 VSS.n1003 0.338
R5572 VSS.n892 VSS.n891 0.338
R5573 VSS.n659 VSS.n655 0.338
R5574 VSS.n660 VSS.n659 0.338
R5575 VSS.n712 VSS.t6 0.3281
R5576 VSS.n712 VSS.t8 0.3281
R5577 VSS.n711 VSS.t2 0.3281
R5578 VSS.n711 VSS.t4 0.3281
R5579 VSS.n620 VSS.t113 0.3281
R5580 VSS.n620 VSS.t116 0.3281
R5581 VSS.n619 VSS.t114 0.3281
R5582 VSS.n619 VSS.t115 0.3281
R5583 VSS.n1209 VSS.n1208 0.3155
R5584 VSS.n1158 VSS.n447 0.3155
R5585 VSS.n1154 VSS.n1153 0.3155
R5586 VSS.n764 VSS.n761 0.3155
R5587 VSS.n850 VSS.n849 0.3155
R5588 VSS.n1114 VSS.n1113 0.309875
R5589 VSS.n1121 VSS.n1096 0.309875
R5590 VSS.n461 VSS.n459 0.309875
R5591 VSS.n498 VSS.n484 0.309875
R5592 VSS.n750 VSS.n596 0.309875
R5593 VSS.n794 VSS.n787 0.309875
R5594 VSS.n836 VSS.n835 0.309875
R5595 VSS.n828 VSS.n607 0.309875
R5596 VSS.n1388 VSS.n285 0.28175
R5597 VSS.n1252 VSS.n1251 0.28175
R5598 VSS.n710 VSS.n623 0.28175
R5599 VSS.n1443 VSS.n122 0.2772
R5600 VSS.n1443 VSS.n121 0.2772
R5601 VSS.n1443 VSS.n120 0.2772
R5602 VSS.n1443 VSS.n119 0.2772
R5603 VSS.n1443 VSS.n118 0.2772
R5604 VSS.n1071 VSS.n514 0.2772
R5605 VSS.n1071 VSS.n512 0.2772
R5606 VSS.n1071 VSS.n515 0.2772
R5607 VSS.n1001 VSS.n543 0.2772
R5608 VSS.n998 VSS.n543 0.2772
R5609 VSS.n547 VSS.n543 0.2772
R5610 VSS.n991 VSS.n543 0.2772
R5611 VSS.n985 VSS.n543 0.2772
R5612 VSS.n874 VSS.n865 0.2772
R5613 VSS.n880 VSS.n865 0.2772
R5614 VSS.n871 VSS.n865 0.2772
R5615 VSS.n887 VSS.n865 0.2772
R5616 VSS.n1464 VSS.n1447 0.2772
R5617 VSS.n1464 VSS.n1446 0.2772
R5618 VSS.n1464 VSS.n1445 0.2772
R5619 VSS.n1521 VSS.n1520 0.2772
R5620 VSS.n1520 VSS.n67 0.2772
R5621 VSS.n283 VSS.n280 0.2705
R5622 VSS.n280 VSS.n274 0.2705
R5623 VSS.n274 VSS.n270 0.2705
R5624 VSS.n216 VSS.n212 0.2705
R5625 VSS.n212 VSS.n206 0.2705
R5626 VSS.n260 VSS.n259 0.2345
R5627 VSS.n217 VSS.n216 0.2345
R5628 VSS.n1305 VSS.n1300 0.2255
R5629 VSS.n1197 VSS.n285 0.2255
R5630 VSS.n228 VSS.n227 0.2165
R5631 VSS.n206 VSS.n61 0.206961
R5632 VSS.n146 VSS.t284 0.20525
R5633 VSS.n146 VSS.t282 0.20525
R5634 VSS.n147 VSS.t445 0.20525
R5635 VSS.n147 VSS.t286 0.20525
R5636 VSS.n149 VSS.t449 0.20525
R5637 VSS.n149 VSS.t447 0.20525
R5638 VSS.n152 VSS.t377 0.20525
R5639 VSS.n152 VSS.t375 0.20525
R5640 VSS.n153 VSS.t288 0.20525
R5641 VSS.n153 VSS.t379 0.20525
R5642 VSS.n155 VSS.t292 0.20525
R5643 VSS.n155 VSS.t290 0.20525
R5644 VSS.n158 VSS.t230 0.20525
R5645 VSS.n158 VSS.t294 0.20525
R5646 VSS.n162 VSS.t217 0.20525
R5647 VSS.n162 VSS.t215 0.20525
R5648 VSS.n161 VSS.t543 0.20525
R5649 VSS.n161 VSS.t219 0.20525
R5650 VSS.n166 VSS.t342 0.20525
R5651 VSS.n166 VSS.t344 0.20525
R5652 VSS.n167 VSS.t330 0.20525
R5653 VSS.n167 VSS.t340 0.20525
R5654 VSS.n169 VSS.t336 0.20525
R5655 VSS.n169 VSS.t338 0.20525
R5656 VSS.n170 VSS.t479 0.20525
R5657 VSS.n170 VSS.t480 0.20525
R5658 VSS.n171 VSS.t475 0.20525
R5659 VSS.n171 VSS.t478 0.20525
R5660 VSS.n173 VSS.t476 0.20525
R5661 VSS.n173 VSS.t477 0.20525
R5662 VSS.n178 VSS.t332 0.20525
R5663 VSS.n178 VSS.t334 0.20525
R5664 VSS.n189 VSS.t298 0.20525
R5665 VSS.n189 VSS.t296 0.20525
R5666 VSS.n190 VSS.t302 0.20525
R5667 VSS.n190 VSS.t300 0.20525
R5668 VSS.n192 VSS.t106 0.20525
R5669 VSS.n192 VSS.t104 0.20525
R5670 VSS.n195 VSS.t110 0.20525
R5671 VSS.n195 VSS.t108 0.20525
R5672 VSS.n198 VSS.t438 0.20525
R5673 VSS.n198 VSS.t436 0.20525
R5674 VSS.n199 VSS.t442 0.20525
R5675 VSS.n199 VSS.t440 0.20525
R5676 VSS.n201 VSS.t234 0.20525
R5677 VSS.n201 VSS.t232 0.20525
R5678 VSS.n185 VSS.t548 0.20525
R5679 VSS.n185 VSS.t546 0.20525
R5680 VSS.n184 VSS.t279 0.20525
R5681 VSS.n184 VSS.t277 0.20525
R5682 VSS.n181 VSS.t82 0.20525
R5683 VSS.n181 VSS.t84 0.20525
R5684 VSS.n54 VSS.t432 0.20525
R5685 VSS.n54 VSS.t430 0.20525
R5686 VSS.n56 VSS.t348 0.20525
R5687 VSS.n56 VSS.t434 0.20525
R5688 VSS.n55 VSS.t352 0.20525
R5689 VSS.n55 VSS.t350 0.20525
R5690 VSS.n45 VSS.t356 0.20525
R5691 VSS.n45 VSS.t354 0.20525
R5692 VSS.n49 VSS.t360 0.20525
R5693 VSS.n49 VSS.t358 0.20525
R5694 VSS.n47 VSS.t366 0.20525
R5695 VSS.n47 VSS.t364 0.20525
R5696 VSS.n46 VSS.t370 0.20525
R5697 VSS.n46 VSS.t368 0.20525
R5698 VSS.n40 VSS.t173 0.20525
R5699 VSS.n40 VSS.t171 0.20525
R5700 VSS.n41 VSS.t169 0.20525
R5701 VSS.n41 VSS.t175 0.20525
R5702 VSS.n22 VSS.t537 0.20525
R5703 VSS.n22 VSS.t539 0.20525
R5704 VSS.n23 VSS.t249 0.20525
R5705 VSS.n23 VSS.t243 0.20525
R5706 VSS.n25 VSS.t245 0.20525
R5707 VSS.n25 VSS.t247 0.20525
R5708 VSS.n24 VSS.t239 0.20525
R5709 VSS.n24 VSS.t241 0.20525
R5710 VSS.n33 VSS.t536 0.20525
R5711 VSS.n33 VSS.t535 0.20525
R5712 VSS.n31 VSS.t533 0.20525
R5713 VSS.n31 VSS.t534 0.20525
R5714 VSS.n30 VSS.t532 0.20525
R5715 VSS.n30 VSS.t530 0.20525
R5716 VSS.n37 VSS.t183 0.20525
R5717 VSS.n37 VSS.t185 0.20525
R5718 VSS.n8 VSS.t422 0.20525
R5719 VSS.n8 VSS.t420 0.20525
R5720 VSS.n12 VSS.t426 0.20525
R5721 VSS.n12 VSS.t424 0.20525
R5722 VSS.n10 VSS.t414 0.20525
R5723 VSS.n10 VSS.t412 0.20525
R5724 VSS.n9 VSS.t418 0.20525
R5725 VSS.n9 VSS.t416 0.20525
R5726 VSS.n2 VSS.t401 0.20525
R5727 VSS.n2 VSS.t409 0.20525
R5728 VSS.n4 VSS.t405 0.20525
R5729 VSS.n4 VSS.t403 0.20525
R5730 VSS.n3 VSS.t399 0.20525
R5731 VSS.n3 VSS.t407 0.20525
R5732 VSS.n17 VSS.t554 0.20525
R5733 VSS.n17 VSS.t552 0.20525
R5734 VSS.n18 VSS.t199 0.20525
R5735 VSS.n18 VSS.t197 0.20525
R5736 VSS.n204 VSS.t521 0.20525
R5737 VSS.n204 VSS.t453 0.20525
R5738 VSS.n219 VSS.t53 0.20525
R5739 VSS.n219 VSS.t55 0.20525
R5740 VSS.n218 VSS.t187 0.20525
R5741 VSS.n218 VSS.t306 0.20525
R5742 VSS.n224 VSS.t45 0.20525
R5743 VSS.n224 VSS.t49 0.20525
R5744 VSS.n222 VSS.t43 0.20525
R5745 VSS.n222 VSS.t47 0.20525
R5746 VSS.n221 VSS.t39 0.20525
R5747 VSS.n221 VSS.t41 0.20525
R5748 VSS.n233 VSS.t67 0.20525
R5749 VSS.n233 VSS.t65 0.20525
R5750 VSS.n231 VSS.t20 0.20525
R5751 VSS.n231 VSS.t18 0.20525
R5752 VSS.n229 VSS.t525 0.20525
R5753 VSS.n229 VSS.t523 0.20525
R5754 VSS.n238 VSS.t61 0.20525
R5755 VSS.n238 VSS.t63 0.20525
R5756 VSS.n236 VSS.t60 0.20525
R5757 VSS.n236 VSS.t56 0.20525
R5758 VSS.n235 VSS.t51 0.20525
R5759 VSS.n235 VSS.t58 0.20525
R5760 VSS.n213 VSS.t124 0.20525
R5761 VSS.n213 VSS.t130 0.20525
R5762 VSS.n214 VSS.t126 0.20525
R5763 VSS.n214 VSS.t128 0.20525
R5764 VSS.n208 VSS.t207 0.20525
R5765 VSS.n208 VSS.t209 0.20525
R5766 VSS.n209 VSS.t203 0.20525
R5767 VSS.n209 VSS.t205 0.20525
R5768 VSS.n262 VSS.t267 0.20525
R5769 VSS.n262 VSS.t261 0.20525
R5770 VSS.n261 VSS.t25 0.20525
R5771 VSS.n261 VSS.t23 0.20525
R5772 VSS.n267 VSS.t264 0.20525
R5773 VSS.n267 VSS.t265 0.20525
R5774 VSS.n265 VSS.t254 0.20525
R5775 VSS.n265 VSS.t259 0.20525
R5776 VSS.n264 VSS.t256 0.20525
R5777 VSS.n264 VSS.t258 0.20525
R5778 VSS.n247 VSS.t459 0.20525
R5779 VSS.n247 VSS.t451 0.20525
R5780 VSS.n251 VSS.t263 0.20525
R5781 VSS.n251 VSS.t253 0.20525
R5782 VSS.n248 VSS.t388 0.20525
R5783 VSS.n248 VSS.t466 0.20525
R5784 VSS.n253 VSS.t274 0.20525
R5785 VSS.n253 VSS.t275 0.20525
R5786 VSS.n255 VSS.t272 0.20525
R5787 VSS.n255 VSS.t273 0.20525
R5788 VSS.n254 VSS.t269 0.20525
R5789 VSS.n254 VSS.t271 0.20525
R5790 VSS.n271 VSS.t560 0.20525
R5791 VSS.n271 VSS.t562 0.20525
R5792 VSS.n272 VSS.t556 0.20525
R5793 VSS.n272 VSS.t558 0.20525
R5794 VSS.n281 VSS.t519 0.20525
R5795 VSS.n281 VSS.t457 0.20525
R5796 VSS.n276 VSS.t494 0.20525
R5797 VSS.n276 VSS.t492 0.20525
R5798 VSS.n277 VSS.t490 0.20525
R5799 VSS.n277 VSS.t493 0.20525
R5800 VSS.n1119 VSS.n1118 0.189974
R5801 VSS.n482 VSS.n481 0.189974
R5802 VSS.n180 VSS.n165 0.189974
R5803 VSS.n156 VSS.n154 0.189974
R5804 VSS.n179 VSS.n177 0.189974
R5805 VSS.n177 VSS.n168 0.189974
R5806 VSS.n193 VSS.n191 0.189974
R5807 VSS.n36 VSS.n21 0.189974
R5808 VSS.n50 VSS.n48 0.189974
R5809 VSS.n34 VSS.n32 0.189974
R5810 VSS.n35 VSS.n34 0.189974
R5811 VSS.n13 VSS.n11 0.189974
R5812 VSS.n792 VSS.n791 0.189974
R5813 VSS.n833 VSS.n831 0.189974
R5814 VSS.n225 VSS.n223 0.189974
R5815 VSS.n225 VSS.n220 0.189974
R5816 VSS.n239 VSS.n237 0.189974
R5817 VSS.n239 VSS.n234 0.189974
R5818 VSS.n268 VSS.n266 0.189974
R5819 VSS.n268 VSS.n263 0.189974
R5820 VSS.n257 VSS.n256 0.189974
R5821 VSS.n257 VSS.n252 0.189974
R5822 VSS.n367 VSS.n366 0.178383
R5823 VSS.n1137 VSS.n463 0.16925
R5824 VSS.n1140 VSS.n1139 0.16925
R5825 VSS.n861 VSS.n860 0.16925
R5826 VSS.n858 VSS.n598 0.16925
R5827 VSS.n714 VSS.n710 0.16925
R5828 VSS.n554 VSS.t511 0.1643
R5829 VSS.n554 VSS.t513 0.1643
R5830 VSS.n553 VSS.t507 0.1643
R5831 VSS.n553 VSS.t509 0.1643
R5832 VSS.n410 VSS.t503 0.1643
R5833 VSS.n410 VSS.t505 0.1643
R5834 VSS.n409 VSS.t501 0.1643
R5835 VSS.n409 VSS.t499 0.1643
R5836 VSS.n657 VSS.t146 0.1643
R5837 VSS.n657 VSS.t140 0.1643
R5838 VSS.n656 VSS.t142 0.1643
R5839 VSS.n656 VSS.t144 0.1643
R5840 VSS.n1193 VSS.t323 0.1643
R5841 VSS.n1193 VSS.t324 0.1643
R5842 VSS.n1195 VSS.t317 0.1643
R5843 VSS.n1195 VSS.t322 0.1643
R5844 VSS.n1301 VSS.t326 0.1643
R5845 VSS.n1301 VSS.t327 0.1643
R5846 VSS.n1302 VSS.t321 0.1643
R5847 VSS.n1302 VSS.t312 0.1643
R5848 VSS.n1120 VSS.n1115 0.1605
R5849 VSS.n483 VSS.n478 0.1605
R5850 VSS.n793 VSS.n788 0.1605
R5851 VSS.n834 VSS.n829 0.1605
R5852 VSS.n1525 VSS.n61 0.144074
R5853 VSS.n1116 VSS.t157 0.137
R5854 VSS.n1116 VSS.t159 0.137
R5855 VSS.n1117 VSS.t153 0.137
R5856 VSS.n1117 VSS.t155 0.137
R5857 VSS.n479 VSS.t162 0.137
R5858 VSS.n479 VSS.t163 0.137
R5859 VSS.n480 VSS.t161 0.137
R5860 VSS.n480 VSS.t160 0.137
R5861 VSS.n789 VSS.t79 0.137
R5862 VSS.n789 VSS.t80 0.137
R5863 VSS.n790 VSS.t72 0.137
R5864 VSS.n790 VSS.t70 0.137
R5865 VSS.n830 VSS.t74 0.137
R5866 VSS.n830 VSS.t78 0.137
R5867 VSS.n832 VSS.t75 0.137
R5868 VSS.n832 VSS.t76 0.137
R5869 VSS.n1304 VSS.n1303 0.118945
R5870 VSS.n1196 VSS.n1194 0.117954
R5871 VSS.n1251 VSS.n412 0.113
R5872 VSS.n976 VSS.n556 0.113
R5873 VSS.n197 VSS.n188 0.0952368
R5874 VSS.n160 VSS.n151 0.0952368
R5875 VSS.n150 VSS.n148 0.0952368
R5876 VSS.n159 VSS.n157 0.0952368
R5877 VSS.n157 VSS.n156 0.0952368
R5878 VSS.n174 VSS.n172 0.0952368
R5879 VSS.n196 VSS.n194 0.0952368
R5880 VSS.n194 VSS.n193 0.0952368
R5881 VSS.n202 VSS.n200 0.0952368
R5882 VSS.n16 VSS.n7 0.0952368
R5883 VSS.n53 VSS.n44 0.0952368
R5884 VSS.n58 VSS.n57 0.0952368
R5885 VSS.n51 VSS.n50 0.0952368
R5886 VSS.n52 VSS.n51 0.0952368
R5887 VSS.n27 VSS.n26 0.0952368
R5888 VSS.n14 VSS.n13 0.0952368
R5889 VSS.n15 VSS.n14 0.0952368
R5890 VSS.n6 VSS.n5 0.0952368
R5891 VSS.n718 VSS.n622 0.05675
R5892 VSS.n259 VSS.n246 0.0545
R5893 VSS.n241 VSS.n228 0.0545
R5894 VSS VSS.n1528 0.0455
R5895 VSS.n270 VSS.n260 0.0365
R5896 VSS.n227 VSS.n217 0.0365
R5897 a_n6400_n23452.n1 a_n6400_n23452.t2 16.0839
R5898 a_n6400_n23452.n1 a_n6400_n23452.n0 12.3065
R5899 a_n6400_n23452.n2 a_n6400_n23452.n1 10.9378
R5900 a_n6400_n23452.n0 a_n6400_n23452.t4 0.1825
R5901 a_n6400_n23452.n0 a_n6400_n23452.t3 0.1825
R5902 a_n6400_n23452.n2 a_n6400_n23452.t1 0.1643
R5903 a_n6400_n23452.t0 a_n6400_n23452.n2 0.1643
R5904 a_n7157_n23500.n1 a_n7157_n23500.t0 16.0839
R5905 a_n7157_n23500.n0 a_n7157_n23500.t2 6.66284
R5906 a_n7157_n23500.t3 a_n7157_n23500.n2 6.62866
R5907 a_n7157_n23500.n0 a_n7157_n23500.t1 6.45713
R5908 a_n7157_n23500.n2 a_n7157_n23500.t4 6.42295
R5909 a_n7157_n23500.n1 a_n7157_n23500.n0 5.97129
R5910 a_n7157_n23500.n2 a_n7157_n23500.n1 4.55024
R5911 a_n10800_n23372.n0 a_n10800_n23372.t3 139.69
R5912 a_n10800_n23372.n0 a_n10800_n23372.t2 139.69
R5913 a_n10800_n23372.n1 a_n10800_n23372.n0 36.7175
R5914 a_n10800_n23372.n1 a_n10800_n23372.t1 14.2148
R5915 a_n10800_n23372.t0 a_n10800_n23372.n1 11.6368
R5916 a_n6400_n21652.n1 a_n6400_n21652.t1 16.0839
R5917 a_n6400_n21652.n1 a_n6400_n21652.n0 12.3065
R5918 a_n6400_n21652.n2 a_n6400_n21652.n1 10.9378
R5919 a_n6400_n21652.n0 a_n6400_n21652.t3 0.1825
R5920 a_n6400_n21652.n0 a_n6400_n21652.t4 0.1825
R5921 a_n6400_n21652.n2 a_n6400_n21652.t2 0.1643
R5922 a_n6400_n21652.t0 a_n6400_n21652.n2 0.1643
R5923 a_n7157_n21700.n1 a_n7157_n21700.t0 16.0839
R5924 a_n7157_n21700.n0 a_n7157_n21700.t2 6.66284
R5925 a_n7157_n21700.t3 a_n7157_n21700.n2 6.62866
R5926 a_n7157_n21700.n0 a_n7157_n21700.t1 6.45713
R5927 a_n7157_n21700.n2 a_n7157_n21700.t4 6.42295
R5928 a_n7157_n21700.n1 a_n7157_n21700.n0 5.97129
R5929 a_n7157_n21700.n2 a_n7157_n21700.n1 4.55024
R5930 a_n10800_n21572.n0 a_n10800_n21572.t3 139.69
R5931 a_n10800_n21572.n0 a_n10800_n21572.t2 139.69
R5932 a_n10800_n21572.n1 a_n10800_n21572.n0 36.7175
R5933 a_n10800_n21572.n1 a_n10800_n21572.t1 14.2148
R5934 a_n10800_n21572.t0 a_n10800_n21572.n1 11.6368
R5935 a_n6400_n19852.n1 a_n6400_n19852.t0 16.1006
R5936 a_n6400_n19852.n2 a_n6400_n19852.n1 12.3065
R5937 a_n6400_n19852.n1 a_n6400_n19852.n0 10.9378
R5938 a_n6400_n19852.t1 a_n6400_n19852.n2 0.1825
R5939 a_n6400_n19852.n2 a_n6400_n19852.t2 0.1825
R5940 a_n6400_n19852.n0 a_n6400_n19852.t3 0.1643
R5941 a_n6400_n19852.n0 a_n6400_n19852.t4 0.1643
R5942 a_n7300_n19900.n1 a_n7300_n19900.t0 16.1006
R5943 a_n7300_n19900.n0 a_n7300_n19900.t3 6.66284
R5944 a_n7300_n19900.n2 a_n7300_n19900.t1 6.62866
R5945 a_n7300_n19900.n0 a_n7300_n19900.t4 6.45713
R5946 a_n7300_n19900.t2 a_n7300_n19900.n2 6.42295
R5947 a_n7300_n19900.n1 a_n7300_n19900.n0 5.97129
R5948 a_n7300_n19900.n2 a_n7300_n19900.n1 4.55024
R5949 a_n10800_n19772.n0 a_n10800_n19772.t3 139.69
R5950 a_n10800_n19772.n0 a_n10800_n19772.t2 139.69
R5951 a_n10800_n19772.n1 a_n10800_n19772.n0 36.7175
R5952 a_n10800_n19772.n1 a_n10800_n19772.t1 14.2148
R5953 a_n10800_n19772.t0 a_n10800_n19772.n1 11.6368
R5954 a_n6400_n18052.n1 a_n6400_n18052.t2 16.1006
R5955 a_n6400_n18052.n2 a_n6400_n18052.n1 12.3065
R5956 a_n6400_n18052.n1 a_n6400_n18052.n0 10.9378
R5957 a_n6400_n18052.n2 a_n6400_n18052.t1 0.1825
R5958 a_n6400_n18052.t0 a_n6400_n18052.n2 0.1825
R5959 a_n6400_n18052.n0 a_n6400_n18052.t4 0.1643
R5960 a_n6400_n18052.n0 a_n6400_n18052.t3 0.1643
R5961 a_n7300_n18100.n1 a_n7300_n18100.t2 16.1006
R5962 a_n7300_n18100.n0 a_n7300_n18100.t4 6.66284
R5963 a_n7300_n18100.n2 a_n7300_n18100.t0 6.62866
R5964 a_n7300_n18100.n0 a_n7300_n18100.t3 6.45713
R5965 a_n7300_n18100.t1 a_n7300_n18100.n2 6.42295
R5966 a_n7300_n18100.n1 a_n7300_n18100.n0 5.97129
R5967 a_n7300_n18100.n2 a_n7300_n18100.n1 4.55024
R5968 a_n10800_n17972.n0 a_n10800_n17972.t3 139.69
R5969 a_n10800_n17972.n0 a_n10800_n17972.t2 139.69
R5970 a_n10800_n17972.n1 a_n10800_n17972.n0 36.7175
R5971 a_n10800_n17972.n1 a_n10800_n17972.t1 14.2148
R5972 a_n10800_n17972.t0 a_n10800_n17972.n1 11.6368
R5973 a_n6400_n16252.n1 a_n6400_n16252.t4 16.1006
R5974 a_n6400_n16252.n2 a_n6400_n16252.n1 12.3065
R5975 a_n6400_n16252.n1 a_n6400_n16252.n0 10.9378
R5976 a_n6400_n16252.t0 a_n6400_n16252.n2 0.1825
R5977 a_n6400_n16252.n2 a_n6400_n16252.t1 0.1825
R5978 a_n6400_n16252.n0 a_n6400_n16252.t2 0.1643
R5979 a_n6400_n16252.n0 a_n6400_n16252.t3 0.1643
R5980 a_n7300_n16300.n1 a_n7300_n16300.t0 16.1006
R5981 a_n7300_n16300.n0 a_n7300_n16300.t3 6.66284
R5982 a_n7300_n16300.n2 a_n7300_n16300.t1 6.62866
R5983 a_n7300_n16300.n0 a_n7300_n16300.t4 6.45713
R5984 a_n7300_n16300.t2 a_n7300_n16300.n2 6.42295
R5985 a_n7300_n16300.n1 a_n7300_n16300.n0 5.97129
R5986 a_n7300_n16300.n2 a_n7300_n16300.n1 4.55024
R5987 a_n10800_n16172.n0 a_n10800_n16172.t3 139.69
R5988 a_n10800_n16172.n0 a_n10800_n16172.t2 139.69
R5989 a_n10800_n16172.n1 a_n10800_n16172.n0 36.7175
R5990 a_n10800_n16172.n1 a_n10800_n16172.t1 14.2148
R5991 a_n10800_n16172.t0 a_n10800_n16172.n1 11.6368
R5992 a_n6400_n14452.n1 a_n6400_n14452.t0 16.1006
R5993 a_n6400_n14452.n2 a_n6400_n14452.n1 12.3065
R5994 a_n6400_n14452.n1 a_n6400_n14452.n0 10.9378
R5995 a_n6400_n14452.n2 a_n6400_n14452.t2 0.1825
R5996 a_n6400_n14452.t1 a_n6400_n14452.n2 0.1825
R5997 a_n6400_n14452.n0 a_n6400_n14452.t4 0.1643
R5998 a_n6400_n14452.n0 a_n6400_n14452.t3 0.1643
R5999 a_n7300_n14500.n1 a_n7300_n14500.t2 16.1006
R6000 a_n7300_n14500.n0 a_n7300_n14500.t4 6.66284
R6001 a_n7300_n14500.n2 a_n7300_n14500.t0 6.62866
R6002 a_n7300_n14500.n0 a_n7300_n14500.t3 6.45713
R6003 a_n7300_n14500.t1 a_n7300_n14500.n2 6.42295
R6004 a_n7300_n14500.n1 a_n7300_n14500.n0 5.97129
R6005 a_n7300_n14500.n2 a_n7300_n14500.n1 4.55024
R6006 a_n10800_n14372.n0 a_n10800_n14372.t3 139.69
R6007 a_n10800_n14372.n0 a_n10800_n14372.t2 139.69
R6008 a_n10800_n14372.n1 a_n10800_n14372.n0 36.7175
R6009 a_n10800_n14372.n1 a_n10800_n14372.t1 14.2148
R6010 a_n10800_n14372.t0 a_n10800_n14372.n1 11.6368
R6011 a_n6400_n12652.n1 a_n6400_n12652.t0 16.1006
R6012 a_n6400_n12652.n2 a_n6400_n12652.n1 12.3065
R6013 a_n6400_n12652.n1 a_n6400_n12652.n0 10.9378
R6014 a_n6400_n12652.t1 a_n6400_n12652.n2 0.1825
R6015 a_n6400_n12652.n2 a_n6400_n12652.t2 0.1825
R6016 a_n6400_n12652.n0 a_n6400_n12652.t4 0.1643
R6017 a_n6400_n12652.n0 a_n6400_n12652.t3 0.1643
R6018 a_n7300_n12700.n1 a_n7300_n12700.t2 16.1006
R6019 a_n7300_n12700.n0 a_n7300_n12700.t4 6.66284
R6020 a_n7300_n12700.n2 a_n7300_n12700.t0 6.62866
R6021 a_n7300_n12700.n0 a_n7300_n12700.t3 6.45713
R6022 a_n7300_n12700.t1 a_n7300_n12700.n2 6.42295
R6023 a_n7300_n12700.n1 a_n7300_n12700.n0 5.97129
R6024 a_n7300_n12700.n2 a_n7300_n12700.n1 4.55024
R6025 a_n10800_n12572.n0 a_n10800_n12572.t3 139.69
R6026 a_n10800_n12572.n0 a_n10800_n12572.t2 139.69
R6027 a_n10800_n12572.n1 a_n10800_n12572.n0 36.7175
R6028 a_n10800_n12572.n1 a_n10800_n12572.t1 14.2148
R6029 a_n10800_n12572.t0 a_n10800_n12572.n1 11.6368
R6030 a_2148_n500.n5 a_2148_n500.n3 10.5451
R6031 a_2148_n500.n5 a_2148_n500.n4 10.5451
R6032 a_2148_n500.n2 a_2148_n500.t1 6.45713
R6033 a_2148_n500.n8 a_2148_n500.n7 6.38754
R6034 a_2148_n500.n1 a_2148_n500.n0 6.29333
R6035 a_2148_n500.n6 a_2148_n500.n2 4.68405
R6036 a_2148_n500.n7 a_2148_n500.n6 2.22659
R6037 a_2148_n500.n6 a_2148_n500.n5 0.8055
R6038 a_2148_n500.n3 a_2148_n500.t6 0.3281
R6039 a_2148_n500.n3 a_2148_n500.t7 0.3281
R6040 a_2148_n500.n4 a_2148_n500.t8 0.3281
R6041 a_2148_n500.n4 a_2148_n500.t0 0.3281
R6042 a_2148_n500.n2 a_2148_n500.n1 0.189974
R6043 a_2148_n500.n8 a_2148_n500.t4 0.1643
R6044 a_2148_n500.t5 a_2148_n500.n8 0.1643
R6045 a_2148_n500.n0 a_2148_n500.t2 0.1643
R6046 a_2148_n500.n0 a_2148_n500.t3 0.1643
R6047 a_2148_n500.n7 a_2148_n500.n1 0.0928953
R6048 a_n5052_n1000.n5 a_n5052_n1000.n3 11.1933
R6049 a_n5052_n1000.n5 a_n5052_n1000.n4 11.1933
R6050 a_n5052_n1000.n2 a_n5052_n1000.t2 6.45713
R6051 a_n5052_n1000.n8 a_n5052_n1000.n7 6.38754
R6052 a_n5052_n1000.n1 a_n5052_n1000.n0 6.29333
R6053 a_n5052_n1000.n6 a_n5052_n1000.n2 4.68405
R6054 a_n5052_n1000.n7 a_n5052_n1000.n6 2.22659
R6055 a_n5052_n1000.n6 a_n5052_n1000.n5 0.5555
R6056 a_n5052_n1000.n2 a_n5052_n1000.n1 0.189974
R6057 a_n5052_n1000.n8 a_n5052_n1000.t5 0.1643
R6058 a_n5052_n1000.t6 a_n5052_n1000.n8 0.1643
R6059 a_n5052_n1000.n0 a_n5052_n1000.t3 0.1643
R6060 a_n5052_n1000.n0 a_n5052_n1000.t4 0.1643
R6061 a_n5052_n1000.n3 a_n5052_n1000.t0 0.1643
R6062 a_n5052_n1000.n3 a_n5052_n1000.t1 0.1643
R6063 a_n5052_n1000.n4 a_n5052_n1000.t8 0.1643
R6064 a_n5052_n1000.n4 a_n5052_n1000.t7 0.1643
R6065 a_n5052_n1000.n7 a_n5052_n1000.n1 0.0928953
R6066 a_n5052_2600.t5 a_n5052_2600.n4 7.27134
R6067 a_n5052_2600.n4 a_n5052_2600.t2 7.27134
R6068 a_n5052_2600.n2 a_n5052_2600.n0 6.71615
R6069 a_n5052_2600.n2 a_n5052_2600.n1 6.71615
R6070 a_n5052_2600.n4 a_n5052_2600.n3 6.31615
R6071 a_n5052_2600.n0 a_n5052_2600.t0 0.8195
R6072 a_n5052_2600.n0 a_n5052_2600.t1 0.8195
R6073 a_n5052_2600.n1 a_n5052_2600.t6 0.8195
R6074 a_n5052_2600.n1 a_n5052_2600.t7 0.8195
R6075 a_n5052_2600.n3 a_n5052_2600.t3 0.8195
R6076 a_n5052_2600.n3 a_n5052_2600.t4 0.8195
R6077 a_n5052_2600.n4 a_n5052_2600.n2 0.3955
R6078 a_5300_5958.t0 a_5300_5958.t1 26.7478
R6079 a_484_3500.t1 a_484_3500.t0 26.7478
R6080 a_n1900_5958.t1 a_n1900_5958.t0 26.7478
R6081 a_n3600_5641.n3 a_n3600_5641.t6 74.5091
R6082 a_n3600_5641.n3 a_n3600_5641.t7 74.5091
R6083 a_n3600_5641.n4 a_n3600_5641.n3 37.8057
R6084 a_n3600_5641.n1 a_n3600_5641.t0 13.0154
R6085 a_n3600_5641.n1 a_n3600_5641.t5 10.6142
R6086 a_n3600_5641.n0 a_n3600_5641.t3 7.23009
R6087 a_n3600_5641.n0 a_n3600_5641.t4 7.22685
R6088 a_n3600_5641.n5 a_n3600_5641.t1 6.55206
R6089 a_n3600_5641.t2 a_n3600_5641.n5 6.54882
R6090 a_n3600_5641.n5 a_n3600_5641.n4 2.75982
R6091 a_n3600_5641.n2 a_n3600_5641.n0 2.26891
R6092 a_n3600_5641.n2 a_n3600_5641.n1 0.425955
R6093 a_n3600_5641.n4 a_n3600_5641.n2 0.393227
R6094 a_n6572_3500.n3 a_n6572_3500.t6 74.5091
R6095 a_n6572_3500.n3 a_n6572_3500.t7 74.5091
R6096 a_n6572_3500.n4 a_n6572_3500.n3 37.5518
R6097 a_n6572_3500.n1 a_n6572_3500.t0 13.0154
R6098 a_n6572_3500.n1 a_n6572_3500.t3 10.6142
R6099 a_n6572_3500.n0 a_n6572_3500.t5 7.23009
R6100 a_n6572_3500.n0 a_n6572_3500.t4 7.22685
R6101 a_n6572_3500.t2 a_n6572_3500.n5 6.55206
R6102 a_n6572_3500.n5 a_n6572_3500.t1 6.54882
R6103 a_n6572_3500.n5 a_n6572_3500.n4 2.59618
R6104 a_n6572_3500.n2 a_n6572_3500.n0 2.26891
R6105 a_n6572_3500.n4 a_n6572_3500.n2 0.556864
R6106 a_n6572_3500.n2 a_n6572_3500.n1 0.425955
R6107 a_n6716_3500.t1 a_n6716_3500.t0 26.7478
R6108 a_n852_19400.n5 a_n852_19400.n3 10.7042
R6109 a_n852_19400.n5 a_n852_19400.n4 10.7042
R6110 a_n852_19400.t5 a_n852_19400.n7 6.77
R6111 a_n852_19400.n2 a_n852_19400.t2 6.6753
R6112 a_n852_19400.n1 a_n852_19400.n0 6.5388
R6113 a_n852_19400.n6 a_n852_19400.n2 4.63668
R6114 a_n852_19400.n7 a_n852_19400.n6 2.23814
R6115 a_n852_19400.n6 a_n852_19400.n5 0.5055
R6116 a_n852_19400.n2 a_n852_19400.n1 0.189974
R6117 a_n852_19400.n3 a_n852_19400.t7 0.1643
R6118 a_n852_19400.n3 a_n852_19400.t6 0.1643
R6119 a_n852_19400.n4 a_n852_19400.t1 0.1643
R6120 a_n852_19400.n4 a_n852_19400.t0 0.1643
R6121 a_n852_19400.n0 a_n852_19400.t3 0.137
R6122 a_n852_19400.n0 a_n852_19400.t4 0.137
R6123 a_n852_19400.n7 a_n852_19400.n1 0.0924286
R6124 a_80148_31500.n5 a_80148_31500.n3 10.5451
R6125 a_80148_31500.n5 a_80148_31500.n4 10.5451
R6126 a_80148_31500.t5 a_80148_31500.n7 6.55182
R6127 a_80148_31500.n2 a_80148_31500.t2 6.45713
R6128 a_80148_31500.n1 a_80148_31500.n0 6.29333
R6129 a_80148_31500.n6 a_80148_31500.n2 4.63668
R6130 a_80148_31500.n7 a_80148_31500.n6 2.23814
R6131 a_80148_31500.n6 a_80148_31500.n5 0.6055
R6132 a_80148_31500.n3 a_80148_31500.t6 0.3281
R6133 a_80148_31500.n3 a_80148_31500.t7 0.3281
R6134 a_80148_31500.n4 a_80148_31500.t0 0.3281
R6135 a_80148_31500.n4 a_80148_31500.t1 0.3281
R6136 a_80148_31500.n2 a_80148_31500.n1 0.189974
R6137 a_80148_31500.n0 a_80148_31500.t3 0.1643
R6138 a_80148_31500.n0 a_80148_31500.t4 0.1643
R6139 a_80148_31500.n7 a_80148_31500.n1 0.0924286
R6140 a_74148_31500.n2 a_74148_31500.n1 15.2138
R6141 a_74148_31500.n2 a_74148_31500.n0 14.8138
R6142 a_74148_31500.n3 a_74148_31500.n2 6.3955
R6143 a_74148_31500.n5 a_74148_31500.t0 6.06762
R6144 a_74148_31500.t3 a_74148_31500.n7 5.97267
R6145 a_74148_31500.n6 a_74148_31500.n4 5.64507
R6146 a_74148_31500.n7 a_74148_31500.n3 4.5005
R6147 a_74148_31500.n5 a_74148_31500.n3 2.40435
R6148 a_74148_31500.n4 a_74148_31500.t1 0.3281
R6149 a_74148_31500.n4 a_74148_31500.t2 0.3281
R6150 a_74148_31500.n0 a_74148_31500.t7 0.3281
R6151 a_74148_31500.n0 a_74148_31500.t6 0.3281
R6152 a_74148_31500.n1 a_74148_31500.t4 0.3281
R6153 a_74148_31500.n1 a_74148_31500.t5 0.3281
R6154 a_74148_31500.n7 a_74148_31500.n6 0.189974
R6155 a_74148_31500.n6 a_74148_31500.n5 0.0921777
R6156 a_72548_31500.n4 a_72548_31500.n2 19.6471
R6157 a_72548_31500.n4 a_72548_31500.n3 19.6471
R6158 a_72548_31500.n6 a_72548_31500.n4 9.3805
R6159 a_72548_31500.t5 a_72548_31500.n7 6.0679
R6160 a_72548_31500.n5 a_72548_31500.t2 5.97267
R6161 a_72548_31500.n1 a_72548_31500.n0 5.64507
R6162 a_72548_31500.n6 a_72548_31500.n5 4.68997
R6163 a_72548_31500.n7 a_72548_31500.n6 2.251
R6164 a_72548_31500.n0 a_72548_31500.t3 0.3281
R6165 a_72548_31500.n0 a_72548_31500.t4 0.3281
R6166 a_72548_31500.n2 a_72548_31500.t6 0.3281
R6167 a_72548_31500.n2 a_72548_31500.t7 0.3281
R6168 a_72548_31500.n3 a_72548_31500.t1 0.3281
R6169 a_72548_31500.n3 a_72548_31500.t0 0.3281
R6170 a_72548_31500.n5 a_72548_31500.n1 0.189974
R6171 a_72548_31500.n7 a_72548_31500.n1 0.0919091
R6172 a_75604_31500.n0 a_75604_31500.t5 74.5091
R6173 a_75604_31500.n0 a_75604_31500.t6 74.5091
R6174 a_75604_31500.n1 a_75604_31500.n0 28.89
R6175 a_75604_31500.n1 a_75604_31500.t0 12.772
R6176 a_75604_31500.n2 a_75604_31500.t4 6.0676
R6177 a_75604_31500.n4 a_75604_31500.t1 6.0676
R6178 a_75604_31500.t2 a_75604_31500.n4 6.06436
R6179 a_75604_31500.n2 a_75604_31500.t3 6.06436
R6180 a_75604_31500.n4 a_75604_31500.n3 2.56391
R6181 a_75604_31500.n3 a_75604_31500.n2 2.56391
R6182 a_75604_31500.n3 a_75604_31500.n1 0.8055
R6183 a_72404_31500.n0 a_72404_31500.t5 74.5091
R6184 a_72404_31500.n0 a_72404_31500.t6 74.5091
R6185 a_72404_31500.n1 a_72404_31500.n0 36.0728
R6186 a_72404_31500.n1 a_72404_31500.t4 12.972
R6187 a_72404_31500.n2 a_72404_31500.t3 6.0676
R6188 a_72404_31500.n4 a_72404_31500.t0 6.0676
R6189 a_72404_31500.t1 a_72404_31500.n4 6.06436
R6190 a_72404_31500.n2 a_72404_31500.t2 6.06436
R6191 a_72404_31500.n4 a_72404_31500.n3 2.56391
R6192 a_72404_31500.n3 a_72404_31500.n2 2.56391
R6193 a_72404_31500.n3 a_72404_31500.n1 0.6055
R6194 a_65148_29400.n5 a_65148_29400.n3 10.7042
R6195 a_65148_29400.n5 a_65148_29400.n4 10.7042
R6196 a_65148_29400.t3 a_65148_29400.n7 6.77
R6197 a_65148_29400.n2 a_65148_29400.t0 6.6753
R6198 a_65148_29400.n1 a_65148_29400.n0 6.5388
R6199 a_65148_29400.n6 a_65148_29400.n2 4.63668
R6200 a_65148_29400.n7 a_65148_29400.n6 2.23814
R6201 a_65148_29400.n6 a_65148_29400.n5 0.5055
R6202 a_65148_29400.n2 a_65148_29400.n1 0.189974
R6203 a_65148_29400.n3 a_65148_29400.t5 0.1643
R6204 a_65148_29400.n3 a_65148_29400.t4 0.1643
R6205 a_65148_29400.n4 a_65148_29400.t7 0.1643
R6206 a_65148_29400.n4 a_65148_29400.t6 0.1643
R6207 a_65148_29400.n0 a_65148_29400.t1 0.137
R6208 a_65148_29400.n0 a_65148_29400.t2 0.137
R6209 a_65148_29400.n7 a_65148_29400.n1 0.0924286
R6210 a_n852_28800.n5 a_n852_28800.n3 10.7042
R6211 a_n852_28800.n5 a_n852_28800.n4 10.7042
R6212 a_n852_28800.t3 a_n852_28800.n7 6.77
R6213 a_n852_28800.n2 a_n852_28800.t0 6.6753
R6214 a_n852_28800.n1 a_n852_28800.n0 6.5388
R6215 a_n852_28800.n6 a_n852_28800.n2 4.63668
R6216 a_n852_28800.n7 a_n852_28800.n6 2.23814
R6217 a_n852_28800.n6 a_n852_28800.n5 0.5055
R6218 a_n852_28800.n2 a_n852_28800.n1 0.189974
R6219 a_n852_28800.n3 a_n852_28800.t4 0.1643
R6220 a_n852_28800.n3 a_n852_28800.t5 0.1643
R6221 a_n852_28800.n4 a_n852_28800.t6 0.1643
R6222 a_n852_28800.n4 a_n852_28800.t7 0.1643
R6223 a_n852_28800.n0 a_n852_28800.t1 0.137
R6224 a_n852_28800.n0 a_n852_28800.t2 0.137
R6225 a_n852_28800.n7 a_n852_28800.n1 0.0924286
R6226 a_600_22678.n0 a_600_22678.t4 139.689
R6227 a_600_22678.n0 a_600_22678.t3 139.689
R6228 a_600_22678.n1 a_600_22678.n0 37.2961
R6229 a_600_22678.n1 a_600_22678.t0 12.557
R6230 a_600_22678.n2 a_600_22678.t1 6.0613
R6231 a_600_22678.t2 a_600_22678.n2 6.0613
R6232 a_600_22678.n2 a_600_22678.n1 2.78832
R6233 a_n1000_22678.n0 a_n1000_22678.t4 139.689
R6234 a_n1000_22678.n0 a_n1000_22678.t3 139.689
R6235 a_n1000_22678.n1 a_n1000_22678.n0 37.2961
R6236 a_n1000_22678.n1 a_n1000_22678.t2 12.557
R6237 a_n1000_22678.n2 a_n1000_22678.t0 6.0613
R6238 a_n1000_22678.t1 a_n1000_22678.n2 6.0613
R6239 a_n1000_22678.n2 a_n1000_22678.n1 2.78832
R6240 a_65148_38800.n5 a_65148_38800.n3 10.7042
R6241 a_65148_38800.n5 a_65148_38800.n4 10.7042
R6242 a_65148_38800.t3 a_65148_38800.n7 6.77
R6243 a_65148_38800.n2 a_65148_38800.t0 6.6753
R6244 a_65148_38800.n1 a_65148_38800.n0 6.5388
R6245 a_65148_38800.n6 a_65148_38800.n2 4.63668
R6246 a_65148_38800.n7 a_65148_38800.n6 2.23814
R6247 a_65148_38800.n6 a_65148_38800.n5 0.5055
R6248 a_65148_38800.n2 a_65148_38800.n1 0.189974
R6249 a_65148_38800.n3 a_65148_38800.t4 0.1643
R6250 a_65148_38800.n3 a_65148_38800.t5 0.1643
R6251 a_65148_38800.n4 a_65148_38800.t6 0.1643
R6252 a_65148_38800.n4 a_65148_38800.t7 0.1643
R6253 a_65148_38800.n0 a_65148_38800.t1 0.137
R6254 a_65148_38800.n0 a_65148_38800.t2 0.137
R6255 a_65148_38800.n7 a_65148_38800.n1 0.0924286
R6256 a_66600_32348.n0 a_66600_32348.t4 139.689
R6257 a_66600_32348.n0 a_66600_32348.t3 139.689
R6258 a_66600_32348.n1 a_66600_32348.n0 37.2961
R6259 a_66600_32348.n1 a_66600_32348.t2 12.392
R6260 a_66600_32348.n2 a_66600_32348.t0 6.0613
R6261 a_66600_32348.t1 a_66600_32348.n2 6.0613
R6262 a_66600_32348.n2 a_66600_32348.n1 2.78832
R6263 a_65000_32348.n0 a_65000_32348.t4 139.689
R6264 a_65000_32348.n0 a_65000_32348.t3 139.689
R6265 a_65000_32348.n1 a_65000_32348.n0 37.2961
R6266 a_65000_32348.n1 a_65000_32348.t0 12.392
R6267 a_65000_32348.n2 a_65000_32348.t1 6.0613
R6268 a_65000_32348.t2 a_65000_32348.n2 6.0613
R6269 a_65000_32348.n2 a_65000_32348.n1 2.78832
R6270 a_11748_41600.n3 a_11748_41600.n1 10.7791
R6271 a_11748_41600.n3 a_11748_41600.n2 10.7791
R6272 a_11748_41600.n0 a_11748_41600.t7 6.55182
R6273 a_11748_41600.n5 a_11748_41600.t4 6.45713
R6274 a_11748_41600.n7 a_11748_41600.n6 6.29333
R6275 a_11748_41600.n5 a_11748_41600.n4 4.63668
R6276 a_11748_41600.n4 a_11748_41600.n0 2.23814
R6277 a_11748_41600.n4 a_11748_41600.n3 0.3305
R6278 a_11748_41600.n1 a_11748_41600.t1 0.20525
R6279 a_11748_41600.n1 a_11748_41600.t0 0.20525
R6280 a_11748_41600.n2 a_11748_41600.t2 0.20525
R6281 a_11748_41600.n2 a_11748_41600.t3 0.20525
R6282 a_11748_41600.n6 a_11748_41600.n5 0.189974
R6283 a_11748_41600.n7 a_11748_41600.t5 0.1643
R6284 a_11748_41600.t6 a_11748_41600.n7 0.1643
R6285 a_11748_41600.n6 a_11748_41600.n0 0.0924286
R6286 a_2148_41600.n3 a_2148_41600.n1 10.7791
R6287 a_2148_41600.n3 a_2148_41600.n2 10.7791
R6288 a_2148_41600.n0 a_2148_41600.t7 6.55182
R6289 a_2148_41600.n5 a_2148_41600.t4 6.45713
R6290 a_2148_41600.n7 a_2148_41600.n6 6.29333
R6291 a_2148_41600.n5 a_2148_41600.n4 4.63668
R6292 a_2148_41600.n4 a_2148_41600.n0 2.23814
R6293 a_2148_41600.n4 a_2148_41600.n3 0.3305
R6294 a_2148_41600.n1 a_2148_41600.t3 0.20525
R6295 a_2148_41600.n1 a_2148_41600.t2 0.20525
R6296 a_2148_41600.n2 a_2148_41600.t1 0.20525
R6297 a_2148_41600.n2 a_2148_41600.t0 0.20525
R6298 a_2148_41600.n6 a_2148_41600.n5 0.189974
R6299 a_2148_41600.n7 a_2148_41600.t5 0.1643
R6300 a_2148_41600.t6 a_2148_41600.n7 0.1643
R6301 a_2148_41600.n6 a_2148_41600.n0 0.0924286
R6302 a_12148_44200.n2 a_12148_44200.n0 15.3662
R6303 a_12148_44200.n2 a_12148_44200.n1 14.5662
R6304 a_12148_44200.n3 a_12148_44200.n2 7.70696
R6305 a_12148_44200.n3 a_12148_44200.t0 5.9772
R6306 a_12148_44200.t1 a_12148_44200.n3 5.9772
R6307 a_12148_44200.n0 a_12148_44200.t5 0.2735
R6308 a_12148_44200.n0 a_12148_44200.t4 0.2735
R6309 a_12148_44200.n1 a_12148_44200.t3 0.2735
R6310 a_12148_44200.n1 a_12148_44200.t2 0.2735
R6311 a_10548_44200.n2 a_10548_44200.n0 19.8662
R6312 a_10548_44200.n2 a_10548_44200.n1 19.3329
R6313 a_10548_44200.n3 a_10548_44200.n2 11.5875
R6314 a_10548_44200.n3 a_10548_44200.t2 5.9772
R6315 a_10548_44200.t3 a_10548_44200.n3 5.9772
R6316 a_10548_44200.n1 a_10548_44200.t1 0.2735
R6317 a_10548_44200.n1 a_10548_44200.t0 0.2735
R6318 a_10548_44200.n0 a_10548_44200.t5 0.2735
R6319 a_10548_44200.n0 a_10548_44200.t4 0.2735
R6320 a_2548_44200.n2 a_2548_44200.n0 15.3662
R6321 a_2548_44200.n2 a_2548_44200.n1 14.5662
R6322 a_2548_44200.n3 a_2548_44200.n2 7.70696
R6323 a_2548_44200.n3 a_2548_44200.t2 5.9772
R6324 a_2548_44200.t3 a_2548_44200.n3 5.9772
R6325 a_2548_44200.n0 a_2548_44200.t5 0.2735
R6326 a_2548_44200.n0 a_2548_44200.t4 0.2735
R6327 a_2548_44200.n1 a_2548_44200.t1 0.2735
R6328 a_2548_44200.n1 a_2548_44200.t0 0.2735
R6329 a_948_44200.n2 a_948_44200.n0 19.8662
R6330 a_948_44200.n2 a_948_44200.n1 19.3329
R6331 a_948_44200.n3 a_948_44200.n2 11.5875
R6332 a_948_44200.n3 a_948_44200.t2 5.9772
R6333 a_948_44200.t3 a_948_44200.n3 5.9772
R6334 a_948_44200.n1 a_948_44200.t1 0.2735
R6335 a_948_44200.n1 a_948_44200.t0 0.2735
R6336 a_948_44200.n0 a_948_44200.t5 0.2735
R6337 a_948_44200.n0 a_948_44200.t4 0.2735
R6338 XRX.XFRONT.XFE_O.NTAIL.n2 XRX.XFRONT.XFE_O.NTAIL.n0 20.6105
R6339 XRX.XFRONT.XFE_O.NTAIL.n10 XRX.XFRONT.XFE_O.NTAIL.n9 18.5365
R6340 XRX.XFRONT.XFE_O.NTAIL.n8 XRX.XFRONT.XFE_O.NTAIL.n7 10.6141
R6341 XRX.XFRONT.XFE_O.NTAIL.n2 XRX.XFRONT.XFE_O.NTAIL.n1 10.6141
R6342 XRX.XFRONT.XFE_O.NTAIL.n4 XRX.XFRONT.XFE_O.NTAIL.t7 5.7796
R6343 XRX.XFRONT.XFE_O.NTAIL.n1 XRX.XFRONT.XFE_O.NTAIL.t1 5.7796
R6344 XRX.XFRONT.XFE_O.NTAIL.n7 XRX.XFRONT.XFE_O.NTAIL.t2 5.68486
R6345 XRX.XFRONT.XFE_O.NTAIL.n1 XRX.XFRONT.XFE_O.NTAIL.t0 5.59012
R6346 XRX.XFRONT.XFE_O.NTAIL.n4 XRX.XFRONT.XFE_O.NTAIL.n3 5.38537
R6347 XRX.XFRONT.XFE_O.NTAIL.n6 XRX.XFRONT.XFE_O.NTAIL.n5 5.38537
R6348 XRX.XFRONT.XFE_O.NTAIL.n8 XRX.XFRONT.XFE_O.NTAIL.n2 2.50485
R6349 XRX.XFRONT.XFE_O.NTAIL.n10 XRX.XFRONT.XFE_O.NTAIL.n8 1.2918
R6350 XRX.XFRONT.XFE_O.NTAIL.n0 XRX.XFRONT.XFE_O.NTAIL.t11 0.20525
R6351 XRX.XFRONT.XFE_O.NTAIL.n0 XRX.XFRONT.XFE_O.NTAIL.t10 0.20525
R6352 XRX.XFRONT.XFE_O.NTAIL.n9 XRX.XFRONT.XFE_O.NTAIL.t8 0.20525
R6353 XRX.XFRONT.XFE_O.NTAIL.n9 XRX.XFRONT.XFE_O.NTAIL.t9 0.20525
R6354 XRX.XFRONT.XFE_O.NTAIL.n3 XRX.XFRONT.XFE_O.NTAIL.t5 0.20525
R6355 XRX.XFRONT.XFE_O.NTAIL.n3 XRX.XFRONT.XFE_O.NTAIL.t6 0.20525
R6356 XRX.XFRONT.XFE_O.NTAIL.n5 XRX.XFRONT.XFE_O.NTAIL.t3 0.20525
R6357 XRX.XFRONT.XFE_O.NTAIL.n5 XRX.XFRONT.XFE_O.NTAIL.t4 0.20525
R6358 XRX.XFRONT.XFE_O.NTAIL.n6 XRX.XFRONT.XFE_O.NTAIL.n4 0.189974
R6359 XRX.XFRONT.XFE_O.NTAIL.n7 XRX.XFRONT.XFE_O.NTAIL.n6 0.0952368
R6360 XRX.XFRONT.XFE_O.NTAIL XRX.XFRONT.XFE_O.NTAIL.n10 0.0396304
R6361 XRX.XFRONT.XFE_E.NTAIL.n3 XRX.XFRONT.XFE_E.NTAIL.n1 20.6105
R6362 XRX.XFRONT.XFE_E.NTAIL XRX.XFRONT.XFE_E.NTAIL.n0 18.5757
R6363 XRX.XFRONT.XFE_E.NTAIL.n9 XRX.XFRONT.XFE_E.NTAIL.n8 10.6141
R6364 XRX.XFRONT.XFE_E.NTAIL.n3 XRX.XFRONT.XFE_E.NTAIL.n2 10.6141
R6365 XRX.XFRONT.XFE_E.NTAIL.n2 XRX.XFRONT.XFE_E.NTAIL.t0 5.7796
R6366 XRX.XFRONT.XFE_E.NTAIL.n5 XRX.XFRONT.XFE_E.NTAIL.t6 5.7796
R6367 XRX.XFRONT.XFE_E.NTAIL.n8 XRX.XFRONT.XFE_E.NTAIL.t11 5.68486
R6368 XRX.XFRONT.XFE_E.NTAIL.n2 XRX.XFRONT.XFE_E.NTAIL.t1 5.59012
R6369 XRX.XFRONT.XFE_E.NTAIL.n7 XRX.XFRONT.XFE_E.NTAIL.n6 5.38537
R6370 XRX.XFRONT.XFE_E.NTAIL.n5 XRX.XFRONT.XFE_E.NTAIL.n4 5.38537
R6371 XRX.XFRONT.XFE_E.NTAIL.n9 XRX.XFRONT.XFE_E.NTAIL.n3 2.50485
R6372 XRX.XFRONT.XFE_E.NTAIL XRX.XFRONT.XFE_E.NTAIL.n9 1.25267
R6373 XRX.XFRONT.XFE_E.NTAIL.n6 XRX.XFRONT.XFE_E.NTAIL.t9 0.20525
R6374 XRX.XFRONT.XFE_E.NTAIL.n6 XRX.XFRONT.XFE_E.NTAIL.t10 0.20525
R6375 XRX.XFRONT.XFE_E.NTAIL.n0 XRX.XFRONT.XFE_E.NTAIL.t4 0.20525
R6376 XRX.XFRONT.XFE_E.NTAIL.n0 XRX.XFRONT.XFE_E.NTAIL.t5 0.20525
R6377 XRX.XFRONT.XFE_E.NTAIL.n1 XRX.XFRONT.XFE_E.NTAIL.t3 0.20525
R6378 XRX.XFRONT.XFE_E.NTAIL.n1 XRX.XFRONT.XFE_E.NTAIL.t2 0.20525
R6379 XRX.XFRONT.XFE_E.NTAIL.n4 XRX.XFRONT.XFE_E.NTAIL.t7 0.20525
R6380 XRX.XFRONT.XFE_E.NTAIL.n4 XRX.XFRONT.XFE_E.NTAIL.t8 0.20525
R6381 XRX.XFRONT.XFE_E.NTAIL.n7 XRX.XFRONT.XFE_E.NTAIL.n5 0.189974
R6382 XRX.XFRONT.XFE_E.NTAIL.n8 XRX.XFRONT.XFE_E.NTAIL.n7 0.0952368
R6383 XRX.XFRONT.XFE_O.BN.n16 XRX.XFRONT.XFE_O.BN.t10 113.632
R6384 XRX.XFRONT.XFE_O.BN.n2 XRX.XFRONT.XFE_O.BN.t23 113.632
R6385 XRX.XFRONT.XFE_O.BN.n6 XRX.XFRONT.XFE_O.BN.t16 113.632
R6386 XRX.XFRONT.XFE_O.BN.n21 XRX.XFRONT.XFE_O.BN.t15 109.174
R6387 XRX.XFRONT.XFE_O.BN.n20 XRX.XFRONT.XFE_O.BN.t14 109.174
R6388 XRX.XFRONT.XFE_O.BN.n19 XRX.XFRONT.XFE_O.BN.t13 109.174
R6389 XRX.XFRONT.XFE_O.BN.n14 XRX.XFRONT.XFE_O.BN.t12 109.174
R6390 XRX.XFRONT.XFE_O.BN.n15 XRX.XFRONT.XFE_O.BN.t11 109.174
R6391 XRX.XFRONT.XFE_O.BN.n9 XRX.XFRONT.XFE_O.BN.t19 109.174
R6392 XRX.XFRONT.XFE_O.BN.n10 XRX.XFRONT.XFE_O.BN.t20 109.174
R6393 XRX.XFRONT.XFE_O.BN.n3 XRX.XFRONT.XFE_O.BN.t22 109.174
R6394 XRX.XFRONT.XFE_O.BN.n4 XRX.XFRONT.XFE_O.BN.t21 109.174
R6395 XRX.XFRONT.XFE_O.BN.n8 XRX.XFRONT.XFE_O.BN.t18 109.174
R6396 XRX.XFRONT.XFE_O.BN.n5 XRX.XFRONT.XFE_O.BN.t17 109.174
R6397 XRX.XFRONT.XFE_O.BN.n22 XRX.XFRONT.XFE_O.BN.n21 18.4942
R6398 XRX.XFRONT.XFE_O.BN.n20 XRX.XFRONT.XFE_O.BN.n13 18.4942
R6399 XRX.XFRONT.XFE_O.BN.n19 XRX.XFRONT.XFE_O.BN.n18 18.4942
R6400 XRX.XFRONT.XFE_O.BN.n17 XRX.XFRONT.XFE_O.BN.n14 18.4942
R6401 XRX.XFRONT.XFE_O.BN.n9 XRX.XFRONT.XFE_O.BN.n0 18.4942
R6402 XRX.XFRONT.XFE_O.BN.n11 XRX.XFRONT.XFE_O.BN.n10 18.4942
R6403 XRX.XFRONT.XFE_O.BN.n4 XRX.XFRONT.XFE_O.BN.n1 18.4942
R6404 XRX.XFRONT.XFE_O.BN.n8 XRX.XFRONT.XFE_O.BN.n7 18.4942
R6405 XRX.XFRONT.XFE_O.BN.n23 XRX.XFRONT.XFE_O.BN.n22 15.5414
R6406 XRX.XFRONT.XFE_O.BN.n21 XRX.XFRONT.XFE_O.BN.n20 11.6805
R6407 XRX.XFRONT.XFE_O.BN.n20 XRX.XFRONT.XFE_O.BN.n19 11.6805
R6408 XRX.XFRONT.XFE_O.BN.n19 XRX.XFRONT.XFE_O.BN.n14 11.6805
R6409 XRX.XFRONT.XFE_O.BN.n15 XRX.XFRONT.XFE_O.BN.n14 11.6805
R6410 XRX.XFRONT.XFE_O.BN.n9 XRX.XFRONT.XFE_O.BN.n8 11.6805
R6411 XRX.XFRONT.XFE_O.BN.n10 XRX.XFRONT.XFE_O.BN.n9 11.6805
R6412 XRX.XFRONT.XFE_O.BN.n4 XRX.XFRONT.XFE_O.BN.n3 11.6805
R6413 XRX.XFRONT.XFE_O.BN.n10 XRX.XFRONT.XFE_O.BN.n4 11.6805
R6414 XRX.XFRONT.XFE_O.BN.n8 XRX.XFRONT.XFE_O.BN.n5 11.6805
R6415 XRX.XFRONT.XFE_O.BN.n23 XRX.XFRONT.XFE_O.BN.n12 9.87478
R6416 XRX.XFRONT.XFE_O.BN.n32 XRX.XFRONT.XFE_O.BN.n31 8.36407
R6417 XRX.XFRONT.XFE_O.BN.n32 XRX.XFRONT.XFE_O.BN.n24 7.91407
R6418 XRX.XFRONT.XFE_O.BN.n17 XRX.XFRONT.XFE_O.BN.n16 7.17687
R6419 XRX.XFRONT.XFE_O.BN.n7 XRX.XFRONT.XFE_O.BN.n6 7.17687
R6420 XRX.XFRONT.XFE_O.BN.n2 XRX.XFRONT.XFE_O.BN.n1 7.17687
R6421 XRX.XFRONT.XFE_O.BN.n33 XRX.XFRONT.XFE_O.BN.n23 6.41789
R6422 XRX.XFRONT.XFE_O.BN.n26 XRX.XFRONT.XFE_O.BN.t0 5.7796
R6423 XRX.XFRONT.XFE_O.BN.n30 XRX.XFRONT.XFE_O.BN.t7 5.7796
R6424 XRX.XFRONT.XFE_O.BN.n24 XRX.XFRONT.XFE_O.BN.t8 5.73764
R6425 XRX.XFRONT.XFE_O.BN.n24 XRX.XFRONT.XFE_O.BN.t9 5.54817
R6426 XRX.XFRONT.XFE_O.BN.n26 XRX.XFRONT.XFE_O.BN.n25 5.38537
R6427 XRX.XFRONT.XFE_O.BN.n28 XRX.XFRONT.XFE_O.BN.n27 5.38537
R6428 XRX.XFRONT.XFE_O.BN.n30 XRX.XFRONT.XFE_O.BN.n29 5.38537
R6429 XRX.XFRONT.XFE_O.BN.n33 XRX.XFRONT.XFE_O.BN.n32 4.5005
R6430 XRX.XFRONT.XFE_O.BN.n16 XRX.XFRONT.XFE_O.BN.n15 4.42851
R6431 XRX.XFRONT.XFE_O.BN.n3 XRX.XFRONT.XFE_O.BN.n2 4.42851
R6432 XRX.XFRONT.XFE_O.BN.n6 XRX.XFRONT.XFE_O.BN.n5 4.42851
R6433 XRX.XFRONT.XFE_O.BN.n25 XRX.XFRONT.XFE_O.BN.t2 0.20525
R6434 XRX.XFRONT.XFE_O.BN.n25 XRX.XFRONT.XFE_O.BN.t1 0.20525
R6435 XRX.XFRONT.XFE_O.BN.n27 XRX.XFRONT.XFE_O.BN.t4 0.20525
R6436 XRX.XFRONT.XFE_O.BN.n27 XRX.XFRONT.XFE_O.BN.t3 0.20525
R6437 XRX.XFRONT.XFE_O.BN.n29 XRX.XFRONT.XFE_O.BN.t6 0.20525
R6438 XRX.XFRONT.XFE_O.BN.n29 XRX.XFRONT.XFE_O.BN.t5 0.20525
R6439 XRX.XFRONT.XFE_O.BN.n28 XRX.XFRONT.XFE_O.BN.n26 0.189974
R6440 XRX.XFRONT.XFE_O.BN.n22 XRX.XFRONT.XFE_O.BN.n13 0.1205
R6441 XRX.XFRONT.XFE_O.BN.n18 XRX.XFRONT.XFE_O.BN.n13 0.1205
R6442 XRX.XFRONT.XFE_O.BN.n18 XRX.XFRONT.XFE_O.BN.n17 0.1205
R6443 XRX.XFRONT.XFE_O.BN.n7 XRX.XFRONT.XFE_O.BN.n0 0.1205
R6444 XRX.XFRONT.XFE_O.BN.n11 XRX.XFRONT.XFE_O.BN.n1 0.1205
R6445 XRX.XFRONT.XFE_O.BN.n31 XRX.XFRONT.XFE_O.BN.n30 0.0952368
R6446 XRX.XFRONT.XFE_O.BN.n31 XRX.XFRONT.XFE_O.BN.n28 0.0952368
R6447 XRX.XFRONT.XFE_O.BN.n12 XRX.XFRONT.XFE_O.BN.n0 0.0485
R6448 XRX.XFRONT.XFE_O.BN.n12 XRX.XFRONT.XFE_O.BN.n11 0.0485
R6449 XRX.XFRONT.XFE_O.BN XRX.XFRONT.XFE_O.BN.n33 0.0396304
R6450 XRX.XFRONT.XFE_O.SXN.n3 XRX.XFRONT.XFE_O.SXN.t19 113.632
R6451 XRX.XFRONT.XFE_O.SXN.n7 XRX.XFRONT.XFE_O.SXN.t12 113.632
R6452 XRX.XFRONT.XFE_O.SXN.n0 XRX.XFRONT.XFE_O.SXN.t20 113.618
R6453 XRX.XFRONT.XFE_O.SXN.n0 XRX.XFRONT.XFE_O.SXN.t21 113.618
R6454 XRX.XFRONT.XFE_O.SXN.n10 XRX.XFRONT.XFE_O.SXN.t15 109.174
R6455 XRX.XFRONT.XFE_O.SXN.n11 XRX.XFRONT.XFE_O.SXN.t16 109.174
R6456 XRX.XFRONT.XFE_O.SXN.n4 XRX.XFRONT.XFE_O.SXN.t18 109.174
R6457 XRX.XFRONT.XFE_O.SXN.n5 XRX.XFRONT.XFE_O.SXN.t17 109.174
R6458 XRX.XFRONT.XFE_O.SXN.n9 XRX.XFRONT.XFE_O.SXN.t14 109.174
R6459 XRX.XFRONT.XFE_O.SXN.n6 XRX.XFRONT.XFE_O.SXN.t13 109.174
R6460 XRX.XFRONT.XFE_O.SXN.n14 XRX.XFRONT.XFE_O.SXN.n0 21.4356
R6461 XRX.XFRONT.XFE_O.SXN.n10 XRX.XFRONT.XFE_O.SXN.n1 18.4942
R6462 XRX.XFRONT.XFE_O.SXN.n12 XRX.XFRONT.XFE_O.SXN.n11 18.4942
R6463 XRX.XFRONT.XFE_O.SXN.n5 XRX.XFRONT.XFE_O.SXN.n2 18.4942
R6464 XRX.XFRONT.XFE_O.SXN.n9 XRX.XFRONT.XFE_O.SXN.n8 18.4942
R6465 XRX.XFRONT.XFE_O.SXN.n26 XRX.XFRONT.XFE_O.SXN.n25 17.1983
R6466 XRX.XFRONT.XFE_O.SXN.n18 XRX.XFRONT.XFE_O.SXN.n17 12.7558
R6467 XRX.XFRONT.XFE_O.SXN.n10 XRX.XFRONT.XFE_O.SXN.n9 11.6805
R6468 XRX.XFRONT.XFE_O.SXN.n11 XRX.XFRONT.XFE_O.SXN.n10 11.6805
R6469 XRX.XFRONT.XFE_O.SXN.n5 XRX.XFRONT.XFE_O.SXN.n4 11.6805
R6470 XRX.XFRONT.XFE_O.SXN.n11 XRX.XFRONT.XFE_O.SXN.n5 11.6805
R6471 XRX.XFRONT.XFE_O.SXN.n9 XRX.XFRONT.XFE_O.SXN.n6 11.6805
R6472 XRX.XFRONT.XFE_O.SXN.n18 XRX.XFRONT.XFE_O.SXN.n14 11.3092
R6473 XRX.XFRONT.XFE_O.SXN.n14 XRX.XFRONT.XFE_O.SXN.n13 10.9034
R6474 XRX.XFRONT.XFE_O.SXN.n8 XRX.XFRONT.XFE_O.SXN.n7 7.17687
R6475 XRX.XFRONT.XFE_O.SXN.n3 XRX.XFRONT.XFE_O.SXN.n2 7.17687
R6476 XRX.XFRONT.XFE_O.SXN.n16 XRX.XFRONT.XFE_O.SXN.t0 5.7796
R6477 XRX.XFRONT.XFE_O.SXN.n20 XRX.XFRONT.XFE_O.SXN.t8 5.73764
R6478 XRX.XFRONT.XFE_O.SXN.n17 XRX.XFRONT.XFE_O.SXN.t3 5.59012
R6479 XRX.XFRONT.XFE_O.SXN.n25 XRX.XFRONT.XFE_O.SXN.t1 5.54817
R6480 XRX.XFRONT.XFE_O.SXN.n16 XRX.XFRONT.XFE_O.SXN.n15 5.38537
R6481 XRX.XFRONT.XFE_O.SXN.n24 XRX.XFRONT.XFE_O.SXN.n23 5.32067
R6482 XRX.XFRONT.XFE_O.SXN.n22 XRX.XFRONT.XFE_O.SXN.n21 5.32067
R6483 XRX.XFRONT.XFE_O.SXN.n20 XRX.XFRONT.XFE_O.SXN.n19 5.32067
R6484 XRX.XFRONT.XFE_O.SXN.n4 XRX.XFRONT.XFE_O.SXN.n3 4.42851
R6485 XRX.XFRONT.XFE_O.SXN.n7 XRX.XFRONT.XFE_O.SXN.n6 4.42851
R6486 XRX.XFRONT.XFE_O.SXN.n26 XRX.XFRONT.XFE_O.SXN.n18 0.313543
R6487 XRX.XFRONT.XFE_O.SXN.n23 XRX.XFRONT.XFE_O.SXN.t9 0.228
R6488 XRX.XFRONT.XFE_O.SXN.n23 XRX.XFRONT.XFE_O.SXN.t2 0.228
R6489 XRX.XFRONT.XFE_O.SXN.n21 XRX.XFRONT.XFE_O.SXN.t11 0.228
R6490 XRX.XFRONT.XFE_O.SXN.n21 XRX.XFRONT.XFE_O.SXN.t10 0.228
R6491 XRX.XFRONT.XFE_O.SXN.n19 XRX.XFRONT.XFE_O.SXN.t7 0.228
R6492 XRX.XFRONT.XFE_O.SXN.n19 XRX.XFRONT.XFE_O.SXN.t6 0.228
R6493 XRX.XFRONT.XFE_O.SXN.n15 XRX.XFRONT.XFE_O.SXN.t5 0.20525
R6494 XRX.XFRONT.XFE_O.SXN.n15 XRX.XFRONT.XFE_O.SXN.t4 0.20525
R6495 XRX.XFRONT.XFE_O.SXN.n17 XRX.XFRONT.XFE_O.SXN.n16 0.189974
R6496 XRX.XFRONT.XFE_O.SXN.n22 XRX.XFRONT.XFE_O.SXN.n20 0.189974
R6497 XRX.XFRONT.XFE_O.SXN.n24 XRX.XFRONT.XFE_O.SXN.n22 0.189974
R6498 XRX.XFRONT.XFE_O.SXN.n25 XRX.XFRONT.XFE_O.SXN.n24 0.189974
R6499 XRX.XFRONT.XFE_O.SXN.n8 XRX.XFRONT.XFE_O.SXN.n1 0.1205
R6500 XRX.XFRONT.XFE_O.SXN.n12 XRX.XFRONT.XFE_O.SXN.n2 0.1205
R6501 XRX.XFRONT.XFE_O.SXN.n13 XRX.XFRONT.XFE_O.SXN.n1 0.0485
R6502 XRX.XFRONT.XFE_O.SXN.n13 XRX.XFRONT.XFE_O.SXN.n12 0.0485
R6503 XRX.XFRONT.XFE_O.SXN XRX.XFRONT.XFE_O.SXN.n26 0.0396304
R6504 XRX.XFRONT.XFE_O.SXP.n14 XRX.XFRONT.XFE_O.SXP.t19 113.632
R6505 XRX.XFRONT.XFE_O.SXP.n18 XRX.XFRONT.XFE_O.SXP.t12 113.632
R6506 XRX.XFRONT.XFE_O.SXP.n11 XRX.XFRONT.XFE_O.SXP.t20 113.618
R6507 XRX.XFRONT.XFE_O.SXP.n11 XRX.XFRONT.XFE_O.SXP.t21 113.618
R6508 XRX.XFRONT.XFE_O.SXP.n21 XRX.XFRONT.XFE_O.SXP.t15 109.174
R6509 XRX.XFRONT.XFE_O.SXP.n22 XRX.XFRONT.XFE_O.SXP.t16 109.174
R6510 XRX.XFRONT.XFE_O.SXP.n15 XRX.XFRONT.XFE_O.SXP.t18 109.174
R6511 XRX.XFRONT.XFE_O.SXP.n16 XRX.XFRONT.XFE_O.SXP.t17 109.174
R6512 XRX.XFRONT.XFE_O.SXP.n20 XRX.XFRONT.XFE_O.SXP.t14 109.174
R6513 XRX.XFRONT.XFE_O.SXP.n17 XRX.XFRONT.XFE_O.SXP.t13 109.174
R6514 XRX.XFRONT.XFE_O.SXP.n25 XRX.XFRONT.XFE_O.SXP.n11 21.8856
R6515 XRX.XFRONT.XFE_O.SXP.n21 XRX.XFRONT.XFE_O.SXP.n12 18.4942
R6516 XRX.XFRONT.XFE_O.SXP.n23 XRX.XFRONT.XFE_O.SXP.n22 18.4942
R6517 XRX.XFRONT.XFE_O.SXP.n16 XRX.XFRONT.XFE_O.SXP.n13 18.4942
R6518 XRX.XFRONT.XFE_O.SXP.n20 XRX.XFRONT.XFE_O.SXP.n19 18.4942
R6519 XRX.XFRONT.XFE_O.SXP.n26 XRX.XFRONT.XFE_O.SXP.n10 15.1644
R6520 XRX.XFRONT.XFE_O.SXP.n21 XRX.XFRONT.XFE_O.SXP.n20 11.6805
R6521 XRX.XFRONT.XFE_O.SXP.n22 XRX.XFRONT.XFE_O.SXP.n21 11.6805
R6522 XRX.XFRONT.XFE_O.SXP.n16 XRX.XFRONT.XFE_O.SXP.n15 11.6805
R6523 XRX.XFRONT.XFE_O.SXP.n22 XRX.XFRONT.XFE_O.SXP.n16 11.6805
R6524 XRX.XFRONT.XFE_O.SXP.n20 XRX.XFRONT.XFE_O.SXP.n17 11.6805
R6525 XRX.XFRONT.XFE_O.SXP.n25 XRX.XFRONT.XFE_O.SXP.n24 10.4534
R6526 XRX.XFRONT.XFE_O.SXP.n10 XRX.XFRONT.XFE_O.SXP.n6 9.54828
R6527 XRX.XFRONT.XFE_O.SXP.n19 XRX.XFRONT.XFE_O.SXP.n18 7.17687
R6528 XRX.XFRONT.XFE_O.SXP.n14 XRX.XFRONT.XFE_O.SXP.n13 7.17687
R6529 XRX.XFRONT.XFE_O.SXP.n8 XRX.XFRONT.XFE_O.SXP.t10 5.7796
R6530 XRX.XFRONT.XFE_O.SXP.n1 XRX.XFRONT.XFE_O.SXP.t4 5.73764
R6531 XRX.XFRONT.XFE_O.SXP.n9 XRX.XFRONT.XFE_O.SXP.t3 5.59012
R6532 XRX.XFRONT.XFE_O.SXP.n6 XRX.XFRONT.XFE_O.SXP.t7 5.54817
R6533 XRX.XFRONT.XFE_O.SXP.n8 XRX.XFRONT.XFE_O.SXP.n7 5.38537
R6534 XRX.XFRONT.XFE_O.SXP.n1 XRX.XFRONT.XFE_O.SXP.n0 5.32067
R6535 XRX.XFRONT.XFE_O.SXP.n3 XRX.XFRONT.XFE_O.SXP.n2 5.32067
R6536 XRX.XFRONT.XFE_O.SXP.n5 XRX.XFRONT.XFE_O.SXP.n4 5.32067
R6537 XRX.XFRONT.XFE_O.SXP.n10 XRX.XFRONT.XFE_O.SXP.n9 4.97418
R6538 XRX.XFRONT.XFE_O.SXP.n26 XRX.XFRONT.XFE_O.SXP.n25 4.5005
R6539 XRX.XFRONT.XFE_O.SXP.n15 XRX.XFRONT.XFE_O.SXP.n14 4.42851
R6540 XRX.XFRONT.XFE_O.SXP.n18 XRX.XFRONT.XFE_O.SXP.n17 4.42851
R6541 XRX.XFRONT.XFE_O.SXP.n0 XRX.XFRONT.XFE_O.SXP.t1 0.228
R6542 XRX.XFRONT.XFE_O.SXP.n0 XRX.XFRONT.XFE_O.SXP.t0 0.228
R6543 XRX.XFRONT.XFE_O.SXP.n2 XRX.XFRONT.XFE_O.SXP.t9 0.228
R6544 XRX.XFRONT.XFE_O.SXP.n2 XRX.XFRONT.XFE_O.SXP.t8 0.228
R6545 XRX.XFRONT.XFE_O.SXP.n4 XRX.XFRONT.XFE_O.SXP.t6 0.228
R6546 XRX.XFRONT.XFE_O.SXP.n4 XRX.XFRONT.XFE_O.SXP.t5 0.228
R6547 XRX.XFRONT.XFE_O.SXP.n7 XRX.XFRONT.XFE_O.SXP.t2 0.20525
R6548 XRX.XFRONT.XFE_O.SXP.n7 XRX.XFRONT.XFE_O.SXP.t11 0.20525
R6549 XRX.XFRONT.XFE_O.SXP.n6 XRX.XFRONT.XFE_O.SXP.n5 0.189974
R6550 XRX.XFRONT.XFE_O.SXP.n5 XRX.XFRONT.XFE_O.SXP.n3 0.189974
R6551 XRX.XFRONT.XFE_O.SXP.n3 XRX.XFRONT.XFE_O.SXP.n1 0.189974
R6552 XRX.XFRONT.XFE_O.SXP.n9 XRX.XFRONT.XFE_O.SXP.n8 0.189974
R6553 XRX.XFRONT.XFE_O.SXP.n19 XRX.XFRONT.XFE_O.SXP.n12 0.1205
R6554 XRX.XFRONT.XFE_O.SXP.n23 XRX.XFRONT.XFE_O.SXP.n13 0.1205
R6555 XRX.XFRONT.XFE_O.SXP.n24 XRX.XFRONT.XFE_O.SXP.n12 0.0485
R6556 XRX.XFRONT.XFE_O.SXP.n24 XRX.XFRONT.XFE_O.SXP.n23 0.0485
R6557 XRX.XFRONT.XFE_O.SXP XRX.XFRONT.XFE_O.SXP.n26 0.0396304
R6558 XRX.XFRONT.XFE_O.BP.n25 XRX.XFRONT.XFE_O.BP.t15 113.632
R6559 XRX.XFRONT.XFE_O.BP.n11 XRX.XFRONT.XFE_O.BP.t23 113.632
R6560 XRX.XFRONT.XFE_O.BP.n15 XRX.XFRONT.XFE_O.BP.t16 113.632
R6561 XRX.XFRONT.XFE_O.BP.n26 XRX.XFRONT.XFE_O.BP.t14 109.174
R6562 XRX.XFRONT.XFE_O.BP.n27 XRX.XFRONT.XFE_O.BP.t13 109.174
R6563 XRX.XFRONT.XFE_O.BP.n28 XRX.XFRONT.XFE_O.BP.t12 109.174
R6564 XRX.XFRONT.XFE_O.BP.n29 XRX.XFRONT.XFE_O.BP.t11 109.174
R6565 XRX.XFRONT.XFE_O.BP.n30 XRX.XFRONT.XFE_O.BP.t10 109.174
R6566 XRX.XFRONT.XFE_O.BP.n18 XRX.XFRONT.XFE_O.BP.t19 109.174
R6567 XRX.XFRONT.XFE_O.BP.n19 XRX.XFRONT.XFE_O.BP.t20 109.174
R6568 XRX.XFRONT.XFE_O.BP.n12 XRX.XFRONT.XFE_O.BP.t22 109.174
R6569 XRX.XFRONT.XFE_O.BP.n13 XRX.XFRONT.XFE_O.BP.t21 109.174
R6570 XRX.XFRONT.XFE_O.BP.n17 XRX.XFRONT.XFE_O.BP.t18 109.174
R6571 XRX.XFRONT.XFE_O.BP.n14 XRX.XFRONT.XFE_O.BP.t17 109.174
R6572 XRX.XFRONT.XFE_O.BP.n27 XRX.XFRONT.XFE_O.BP.n24 18.4942
R6573 XRX.XFRONT.XFE_O.BP.n28 XRX.XFRONT.XFE_O.BP.n23 18.4942
R6574 XRX.XFRONT.XFE_O.BP.n29 XRX.XFRONT.XFE_O.BP.n22 18.4942
R6575 XRX.XFRONT.XFE_O.BP.n31 XRX.XFRONT.XFE_O.BP.n30 18.4942
R6576 XRX.XFRONT.XFE_O.BP.n18 XRX.XFRONT.XFE_O.BP.n9 18.4942
R6577 XRX.XFRONT.XFE_O.BP.n20 XRX.XFRONT.XFE_O.BP.n19 18.4942
R6578 XRX.XFRONT.XFE_O.BP.n13 XRX.XFRONT.XFE_O.BP.n10 18.4942
R6579 XRX.XFRONT.XFE_O.BP.n17 XRX.XFRONT.XFE_O.BP.n16 18.4942
R6580 XRX.XFRONT.XFE_O.BP.n32 XRX.XFRONT.XFE_O.BP.n31 15.0914
R6581 XRX.XFRONT.XFE_O.BP.n27 XRX.XFRONT.XFE_O.BP.n26 11.6805
R6582 XRX.XFRONT.XFE_O.BP.n28 XRX.XFRONT.XFE_O.BP.n27 11.6805
R6583 XRX.XFRONT.XFE_O.BP.n29 XRX.XFRONT.XFE_O.BP.n28 11.6805
R6584 XRX.XFRONT.XFE_O.BP.n30 XRX.XFRONT.XFE_O.BP.n29 11.6805
R6585 XRX.XFRONT.XFE_O.BP.n18 XRX.XFRONT.XFE_O.BP.n17 11.6805
R6586 XRX.XFRONT.XFE_O.BP.n19 XRX.XFRONT.XFE_O.BP.n18 11.6805
R6587 XRX.XFRONT.XFE_O.BP.n13 XRX.XFRONT.XFE_O.BP.n12 11.6805
R6588 XRX.XFRONT.XFE_O.BP.n19 XRX.XFRONT.XFE_O.BP.n13 11.6805
R6589 XRX.XFRONT.XFE_O.BP.n17 XRX.XFRONT.XFE_O.BP.n14 11.6805
R6590 XRX.XFRONT.XFE_O.BP.n32 XRX.XFRONT.XFE_O.BP.n21 10.3248
R6591 XRX.XFRONT.XFE_O.BP.n8 XRX.XFRONT.XFE_O.BP.n0 8.36407
R6592 XRX.XFRONT.XFE_O.BP.n8 XRX.XFRONT.XFE_O.BP.n7 7.91407
R6593 XRX.XFRONT.XFE_O.BP.n25 XRX.XFRONT.XFE_O.BP.n24 7.17687
R6594 XRX.XFRONT.XFE_O.BP.n16 XRX.XFRONT.XFE_O.BP.n15 7.17687
R6595 XRX.XFRONT.XFE_O.BP.n11 XRX.XFRONT.XFE_O.BP.n10 7.17687
R6596 XRX.XFRONT.XFE_O.BP.n33 XRX.XFRONT.XFE_O.BP.n8 6.10485
R6597 XRX.XFRONT.XFE_O.BP.n2 XRX.XFRONT.XFE_O.BP.t9 5.7796
R6598 XRX.XFRONT.XFE_O.BP.n6 XRX.XFRONT.XFE_O.BP.t2 5.7796
R6599 XRX.XFRONT.XFE_O.BP.n0 XRX.XFRONT.XFE_O.BP.t1 5.73764
R6600 XRX.XFRONT.XFE_O.BP.n0 XRX.XFRONT.XFE_O.BP.t0 5.54817
R6601 XRX.XFRONT.XFE_O.BP.n2 XRX.XFRONT.XFE_O.BP.n1 5.38537
R6602 XRX.XFRONT.XFE_O.BP.n4 XRX.XFRONT.XFE_O.BP.n3 5.38537
R6603 XRX.XFRONT.XFE_O.BP.n6 XRX.XFRONT.XFE_O.BP.n5 5.38537
R6604 XRX.XFRONT.XFE_O.BP.n33 XRX.XFRONT.XFE_O.BP.n32 4.5005
R6605 XRX.XFRONT.XFE_O.BP.n26 XRX.XFRONT.XFE_O.BP.n25 4.42851
R6606 XRX.XFRONT.XFE_O.BP.n12 XRX.XFRONT.XFE_O.BP.n11 4.42851
R6607 XRX.XFRONT.XFE_O.BP.n15 XRX.XFRONT.XFE_O.BP.n14 4.42851
R6608 XRX.XFRONT.XFE_O.BP.n1 XRX.XFRONT.XFE_O.BP.t7 0.20525
R6609 XRX.XFRONT.XFE_O.BP.n1 XRX.XFRONT.XFE_O.BP.t8 0.20525
R6610 XRX.XFRONT.XFE_O.BP.n3 XRX.XFRONT.XFE_O.BP.t5 0.20525
R6611 XRX.XFRONT.XFE_O.BP.n3 XRX.XFRONT.XFE_O.BP.t6 0.20525
R6612 XRX.XFRONT.XFE_O.BP.n5 XRX.XFRONT.XFE_O.BP.t3 0.20525
R6613 XRX.XFRONT.XFE_O.BP.n5 XRX.XFRONT.XFE_O.BP.t4 0.20525
R6614 XRX.XFRONT.XFE_O.BP.n4 XRX.XFRONT.XFE_O.BP.n2 0.189974
R6615 XRX.XFRONT.XFE_O.BP.n24 XRX.XFRONT.XFE_O.BP.n23 0.1205
R6616 XRX.XFRONT.XFE_O.BP.n23 XRX.XFRONT.XFE_O.BP.n22 0.1205
R6617 XRX.XFRONT.XFE_O.BP.n31 XRX.XFRONT.XFE_O.BP.n22 0.1205
R6618 XRX.XFRONT.XFE_O.BP.n16 XRX.XFRONT.XFE_O.BP.n9 0.1205
R6619 XRX.XFRONT.XFE_O.BP.n20 XRX.XFRONT.XFE_O.BP.n10 0.1205
R6620 XRX.XFRONT.XFE_O.BP.n7 XRX.XFRONT.XFE_O.BP.n6 0.0952368
R6621 XRX.XFRONT.XFE_O.BP.n7 XRX.XFRONT.XFE_O.BP.n4 0.0952368
R6622 XRX.XFRONT.XFE_O.BP.n21 XRX.XFRONT.XFE_O.BP.n9 0.0485
R6623 XRX.XFRONT.XFE_O.BP.n21 XRX.XFRONT.XFE_O.BP.n20 0.0485
R6624 XRX.XFRONT.XFE_O.BP XRX.XFRONT.XFE_O.BP.n33 0.0396304
R6625 XRX.XFRONT.XFE_E.BP.n16 XRX.XFRONT.XFE_E.BP.t10 113.632
R6626 XRX.XFRONT.XFE_E.BP.n2 XRX.XFRONT.XFE_E.BP.t23 113.632
R6627 XRX.XFRONT.XFE_E.BP.n6 XRX.XFRONT.XFE_E.BP.t16 113.632
R6628 XRX.XFRONT.XFE_E.BP.n21 XRX.XFRONT.XFE_E.BP.t15 109.174
R6629 XRX.XFRONT.XFE_E.BP.n20 XRX.XFRONT.XFE_E.BP.t14 109.174
R6630 XRX.XFRONT.XFE_E.BP.n19 XRX.XFRONT.XFE_E.BP.t13 109.174
R6631 XRX.XFRONT.XFE_E.BP.n14 XRX.XFRONT.XFE_E.BP.t12 109.174
R6632 XRX.XFRONT.XFE_E.BP.n15 XRX.XFRONT.XFE_E.BP.t11 109.174
R6633 XRX.XFRONT.XFE_E.BP.n9 XRX.XFRONT.XFE_E.BP.t19 109.174
R6634 XRX.XFRONT.XFE_E.BP.n10 XRX.XFRONT.XFE_E.BP.t20 109.174
R6635 XRX.XFRONT.XFE_E.BP.n3 XRX.XFRONT.XFE_E.BP.t22 109.174
R6636 XRX.XFRONT.XFE_E.BP.n4 XRX.XFRONT.XFE_E.BP.t21 109.174
R6637 XRX.XFRONT.XFE_E.BP.n8 XRX.XFRONT.XFE_E.BP.t18 109.174
R6638 XRX.XFRONT.XFE_E.BP.n5 XRX.XFRONT.XFE_E.BP.t17 109.174
R6639 XRX.XFRONT.XFE_E.BP.n22 XRX.XFRONT.XFE_E.BP.n21 18.4942
R6640 XRX.XFRONT.XFE_E.BP.n20 XRX.XFRONT.XFE_E.BP.n13 18.4942
R6641 XRX.XFRONT.XFE_E.BP.n19 XRX.XFRONT.XFE_E.BP.n18 18.4942
R6642 XRX.XFRONT.XFE_E.BP.n17 XRX.XFRONT.XFE_E.BP.n14 18.4942
R6643 XRX.XFRONT.XFE_E.BP.n9 XRX.XFRONT.XFE_E.BP.n0 18.4942
R6644 XRX.XFRONT.XFE_E.BP.n11 XRX.XFRONT.XFE_E.BP.n10 18.4942
R6645 XRX.XFRONT.XFE_E.BP.n4 XRX.XFRONT.XFE_E.BP.n1 18.4942
R6646 XRX.XFRONT.XFE_E.BP.n8 XRX.XFRONT.XFE_E.BP.n7 18.4942
R6647 XRX.XFRONT.XFE_E.BP.n23 XRX.XFRONT.XFE_E.BP.n22 15.0914
R6648 XRX.XFRONT.XFE_E.BP.n21 XRX.XFRONT.XFE_E.BP.n20 11.6805
R6649 XRX.XFRONT.XFE_E.BP.n20 XRX.XFRONT.XFE_E.BP.n19 11.6805
R6650 XRX.XFRONT.XFE_E.BP.n19 XRX.XFRONT.XFE_E.BP.n14 11.6805
R6651 XRX.XFRONT.XFE_E.BP.n15 XRX.XFRONT.XFE_E.BP.n14 11.6805
R6652 XRX.XFRONT.XFE_E.BP.n9 XRX.XFRONT.XFE_E.BP.n8 11.6805
R6653 XRX.XFRONT.XFE_E.BP.n10 XRX.XFRONT.XFE_E.BP.n9 11.6805
R6654 XRX.XFRONT.XFE_E.BP.n4 XRX.XFRONT.XFE_E.BP.n3 11.6805
R6655 XRX.XFRONT.XFE_E.BP.n10 XRX.XFRONT.XFE_E.BP.n4 11.6805
R6656 XRX.XFRONT.XFE_E.BP.n8 XRX.XFRONT.XFE_E.BP.n5 11.6805
R6657 XRX.XFRONT.XFE_E.BP.n23 XRX.XFRONT.XFE_E.BP.n12 10.3248
R6658 XRX.XFRONT.XFE_E.BP.n32 XRX.XFRONT.XFE_E.BP.n24 8.36407
R6659 XRX.XFRONT.XFE_E.BP.n32 XRX.XFRONT.XFE_E.BP.n31 7.91407
R6660 XRX.XFRONT.XFE_E.BP.n17 XRX.XFRONT.XFE_E.BP.n16 7.17687
R6661 XRX.XFRONT.XFE_E.BP.n7 XRX.XFRONT.XFE_E.BP.n6 7.17687
R6662 XRX.XFRONT.XFE_E.BP.n2 XRX.XFRONT.XFE_E.BP.n1 7.17687
R6663 XRX.XFRONT.XFE_E.BP XRX.XFRONT.XFE_E.BP.n32 6.06572
R6664 XRX.XFRONT.XFE_E.BP.n28 XRX.XFRONT.XFE_E.BP.t0 5.7796
R6665 XRX.XFRONT.XFE_E.BP.n26 XRX.XFRONT.XFE_E.BP.t7 5.7796
R6666 XRX.XFRONT.XFE_E.BP.n24 XRX.XFRONT.XFE_E.BP.t2 5.73764
R6667 XRX.XFRONT.XFE_E.BP.n24 XRX.XFRONT.XFE_E.BP.t1 5.54817
R6668 XRX.XFRONT.XFE_E.BP.n26 XRX.XFRONT.XFE_E.BP.n25 5.38537
R6669 XRX.XFRONT.XFE_E.BP.n30 XRX.XFRONT.XFE_E.BP.n29 5.38537
R6670 XRX.XFRONT.XFE_E.BP.n28 XRX.XFRONT.XFE_E.BP.n27 5.38537
R6671 XRX.XFRONT.XFE_E.BP XRX.XFRONT.XFE_E.BP.n23 4.53963
R6672 XRX.XFRONT.XFE_E.BP.n16 XRX.XFRONT.XFE_E.BP.n15 4.42851
R6673 XRX.XFRONT.XFE_E.BP.n3 XRX.XFRONT.XFE_E.BP.n2 4.42851
R6674 XRX.XFRONT.XFE_E.BP.n6 XRX.XFRONT.XFE_E.BP.n5 4.42851
R6675 XRX.XFRONT.XFE_E.BP.n25 XRX.XFRONT.XFE_E.BP.t9 0.20525
R6676 XRX.XFRONT.XFE_E.BP.n25 XRX.XFRONT.XFE_E.BP.t8 0.20525
R6677 XRX.XFRONT.XFE_E.BP.n29 XRX.XFRONT.XFE_E.BP.t4 0.20525
R6678 XRX.XFRONT.XFE_E.BP.n29 XRX.XFRONT.XFE_E.BP.t3 0.20525
R6679 XRX.XFRONT.XFE_E.BP.n27 XRX.XFRONT.XFE_E.BP.t6 0.20525
R6680 XRX.XFRONT.XFE_E.BP.n27 XRX.XFRONT.XFE_E.BP.t5 0.20525
R6681 XRX.XFRONT.XFE_E.BP.n30 XRX.XFRONT.XFE_E.BP.n28 0.189974
R6682 XRX.XFRONT.XFE_E.BP.n22 XRX.XFRONT.XFE_E.BP.n13 0.1205
R6683 XRX.XFRONT.XFE_E.BP.n18 XRX.XFRONT.XFE_E.BP.n13 0.1205
R6684 XRX.XFRONT.XFE_E.BP.n18 XRX.XFRONT.XFE_E.BP.n17 0.1205
R6685 XRX.XFRONT.XFE_E.BP.n7 XRX.XFRONT.XFE_E.BP.n0 0.1205
R6686 XRX.XFRONT.XFE_E.BP.n11 XRX.XFRONT.XFE_E.BP.n1 0.1205
R6687 XRX.XFRONT.XFE_E.BP.n31 XRX.XFRONT.XFE_E.BP.n30 0.0952368
R6688 XRX.XFRONT.XFE_E.BP.n31 XRX.XFRONT.XFE_E.BP.n26 0.0952368
R6689 XRX.XFRONT.XFE_E.BP.n12 XRX.XFRONT.XFE_E.BP.n0 0.0485
R6690 XRX.XFRONT.XFE_E.BP.n12 XRX.XFRONT.XFE_E.BP.n11 0.0485
R6691 XRX.XFRONT.XFE_E.SXP.n3 XRX.XFRONT.XFE_E.SXP.t19 113.632
R6692 XRX.XFRONT.XFE_E.SXP.n7 XRX.XFRONT.XFE_E.SXP.t12 113.632
R6693 XRX.XFRONT.XFE_E.SXP.n0 XRX.XFRONT.XFE_E.SXP.t20 113.618
R6694 XRX.XFRONT.XFE_E.SXP.n0 XRX.XFRONT.XFE_E.SXP.t21 113.618
R6695 XRX.XFRONT.XFE_E.SXP.n10 XRX.XFRONT.XFE_E.SXP.t15 109.174
R6696 XRX.XFRONT.XFE_E.SXP.n11 XRX.XFRONT.XFE_E.SXP.t16 109.174
R6697 XRX.XFRONT.XFE_E.SXP.n4 XRX.XFRONT.XFE_E.SXP.t18 109.174
R6698 XRX.XFRONT.XFE_E.SXP.n5 XRX.XFRONT.XFE_E.SXP.t17 109.174
R6699 XRX.XFRONT.XFE_E.SXP.n9 XRX.XFRONT.XFE_E.SXP.t14 109.174
R6700 XRX.XFRONT.XFE_E.SXP.n6 XRX.XFRONT.XFE_E.SXP.t13 109.174
R6701 XRX.XFRONT.XFE_E.SXP.n14 XRX.XFRONT.XFE_E.SXP.n0 21.8856
R6702 XRX.XFRONT.XFE_E.SXP.n10 XRX.XFRONT.XFE_E.SXP.n1 18.4942
R6703 XRX.XFRONT.XFE_E.SXP.n12 XRX.XFRONT.XFE_E.SXP.n11 18.4942
R6704 XRX.XFRONT.XFE_E.SXP.n5 XRX.XFRONT.XFE_E.SXP.n2 18.4942
R6705 XRX.XFRONT.XFE_E.SXP.n9 XRX.XFRONT.XFE_E.SXP.n8 18.4942
R6706 XRX.XFRONT.XFE_E.SXP XRX.XFRONT.XFE_E.SXP.n25 15.1253
R6707 XRX.XFRONT.XFE_E.SXP.n10 XRX.XFRONT.XFE_E.SXP.n9 11.6805
R6708 XRX.XFRONT.XFE_E.SXP.n11 XRX.XFRONT.XFE_E.SXP.n10 11.6805
R6709 XRX.XFRONT.XFE_E.SXP.n5 XRX.XFRONT.XFE_E.SXP.n4 11.6805
R6710 XRX.XFRONT.XFE_E.SXP.n11 XRX.XFRONT.XFE_E.SXP.n5 11.6805
R6711 XRX.XFRONT.XFE_E.SXP.n9 XRX.XFRONT.XFE_E.SXP.n6 11.6805
R6712 XRX.XFRONT.XFE_E.SXP.n14 XRX.XFRONT.XFE_E.SXP.n13 10.4534
R6713 XRX.XFRONT.XFE_E.SXP.n25 XRX.XFRONT.XFE_E.SXP.n21 9.54828
R6714 XRX.XFRONT.XFE_E.SXP.n8 XRX.XFRONT.XFE_E.SXP.n7 7.17687
R6715 XRX.XFRONT.XFE_E.SXP.n3 XRX.XFRONT.XFE_E.SXP.n2 7.17687
R6716 XRX.XFRONT.XFE_E.SXP.n23 XRX.XFRONT.XFE_E.SXP.t9 5.7796
R6717 XRX.XFRONT.XFE_E.SXP.n16 XRX.XFRONT.XFE_E.SXP.t5 5.73764
R6718 XRX.XFRONT.XFE_E.SXP.n24 XRX.XFRONT.XFE_E.SXP.t6 5.59012
R6719 XRX.XFRONT.XFE_E.SXP.n21 XRX.XFRONT.XFE_E.SXP.t10 5.54817
R6720 XRX.XFRONT.XFE_E.SXP.n23 XRX.XFRONT.XFE_E.SXP.n22 5.38537
R6721 XRX.XFRONT.XFE_E.SXP.n20 XRX.XFRONT.XFE_E.SXP.n19 5.32067
R6722 XRX.XFRONT.XFE_E.SXP.n18 XRX.XFRONT.XFE_E.SXP.n17 5.32067
R6723 XRX.XFRONT.XFE_E.SXP.n16 XRX.XFRONT.XFE_E.SXP.n15 5.32067
R6724 XRX.XFRONT.XFE_E.SXP.n25 XRX.XFRONT.XFE_E.SXP.n24 4.97418
R6725 XRX.XFRONT.XFE_E.SXP XRX.XFRONT.XFE_E.SXP.n14 4.53963
R6726 XRX.XFRONT.XFE_E.SXP.n4 XRX.XFRONT.XFE_E.SXP.n3 4.42851
R6727 XRX.XFRONT.XFE_E.SXP.n7 XRX.XFRONT.XFE_E.SXP.n6 4.42851
R6728 XRX.XFRONT.XFE_E.SXP.n19 XRX.XFRONT.XFE_E.SXP.t0 0.228
R6729 XRX.XFRONT.XFE_E.SXP.n19 XRX.XFRONT.XFE_E.SXP.t11 0.228
R6730 XRX.XFRONT.XFE_E.SXP.n17 XRX.XFRONT.XFE_E.SXP.t2 0.228
R6731 XRX.XFRONT.XFE_E.SXP.n17 XRX.XFRONT.XFE_E.SXP.t1 0.228
R6732 XRX.XFRONT.XFE_E.SXP.n15 XRX.XFRONT.XFE_E.SXP.t4 0.228
R6733 XRX.XFRONT.XFE_E.SXP.n15 XRX.XFRONT.XFE_E.SXP.t3 0.228
R6734 XRX.XFRONT.XFE_E.SXP.n22 XRX.XFRONT.XFE_E.SXP.t8 0.20525
R6735 XRX.XFRONT.XFE_E.SXP.n22 XRX.XFRONT.XFE_E.SXP.t7 0.20525
R6736 XRX.XFRONT.XFE_E.SXP.n18 XRX.XFRONT.XFE_E.SXP.n16 0.189974
R6737 XRX.XFRONT.XFE_E.SXP.n20 XRX.XFRONT.XFE_E.SXP.n18 0.189974
R6738 XRX.XFRONT.XFE_E.SXP.n21 XRX.XFRONT.XFE_E.SXP.n20 0.189974
R6739 XRX.XFRONT.XFE_E.SXP.n24 XRX.XFRONT.XFE_E.SXP.n23 0.189974
R6740 XRX.XFRONT.XFE_E.SXP.n8 XRX.XFRONT.XFE_E.SXP.n1 0.1205
R6741 XRX.XFRONT.XFE_E.SXP.n12 XRX.XFRONT.XFE_E.SXP.n2 0.1205
R6742 XRX.XFRONT.XFE_E.SXP.n13 XRX.XFRONT.XFE_E.SXP.n1 0.0485
R6743 XRX.XFRONT.XFE_E.SXP.n13 XRX.XFRONT.XFE_E.SXP.n12 0.0485
R6744 XRX.XFRONT.XFE_E.SXN.n10 XRX.XFRONT.XFE_E.SXN.t19 113.632
R6745 XRX.XFRONT.XFE_E.SXN.n14 XRX.XFRONT.XFE_E.SXN.t12 113.632
R6746 XRX.XFRONT.XFE_E.SXN.n7 XRX.XFRONT.XFE_E.SXN.t20 113.618
R6747 XRX.XFRONT.XFE_E.SXN.n7 XRX.XFRONT.XFE_E.SXN.t21 113.618
R6748 XRX.XFRONT.XFE_E.SXN.n17 XRX.XFRONT.XFE_E.SXN.t15 109.174
R6749 XRX.XFRONT.XFE_E.SXN.n18 XRX.XFRONT.XFE_E.SXN.t16 109.174
R6750 XRX.XFRONT.XFE_E.SXN.n11 XRX.XFRONT.XFE_E.SXN.t18 109.174
R6751 XRX.XFRONT.XFE_E.SXN.n12 XRX.XFRONT.XFE_E.SXN.t17 109.174
R6752 XRX.XFRONT.XFE_E.SXN.n16 XRX.XFRONT.XFE_E.SXN.t14 109.174
R6753 XRX.XFRONT.XFE_E.SXN.n13 XRX.XFRONT.XFE_E.SXN.t13 109.174
R6754 XRX.XFRONT.XFE_E.SXN.n21 XRX.XFRONT.XFE_E.SXN.n7 21.4356
R6755 XRX.XFRONT.XFE_E.SXN.n17 XRX.XFRONT.XFE_E.SXN.n8 18.4942
R6756 XRX.XFRONT.XFE_E.SXN.n19 XRX.XFRONT.XFE_E.SXN.n18 18.4942
R6757 XRX.XFRONT.XFE_E.SXN.n12 XRX.XFRONT.XFE_E.SXN.n9 18.4942
R6758 XRX.XFRONT.XFE_E.SXN.n16 XRX.XFRONT.XFE_E.SXN.n15 18.4942
R6759 XRX.XFRONT.XFE_E.SXN XRX.XFRONT.XFE_E.SXN.n6 17.2374
R6760 XRX.XFRONT.XFE_E.SXN.n25 XRX.XFRONT.XFE_E.SXN.n24 12.7558
R6761 XRX.XFRONT.XFE_E.SXN.n17 XRX.XFRONT.XFE_E.SXN.n16 11.6805
R6762 XRX.XFRONT.XFE_E.SXN.n18 XRX.XFRONT.XFE_E.SXN.n17 11.6805
R6763 XRX.XFRONT.XFE_E.SXN.n12 XRX.XFRONT.XFE_E.SXN.n11 11.6805
R6764 XRX.XFRONT.XFE_E.SXN.n18 XRX.XFRONT.XFE_E.SXN.n12 11.6805
R6765 XRX.XFRONT.XFE_E.SXN.n16 XRX.XFRONT.XFE_E.SXN.n13 11.6805
R6766 XRX.XFRONT.XFE_E.SXN.n25 XRX.XFRONT.XFE_E.SXN.n21 11.3092
R6767 XRX.XFRONT.XFE_E.SXN.n21 XRX.XFRONT.XFE_E.SXN.n20 10.9034
R6768 XRX.XFRONT.XFE_E.SXN.n15 XRX.XFRONT.XFE_E.SXN.n14 7.17687
R6769 XRX.XFRONT.XFE_E.SXN.n10 XRX.XFRONT.XFE_E.SXN.n9 7.17687
R6770 XRX.XFRONT.XFE_E.SXN.n23 XRX.XFRONT.XFE_E.SXN.t10 5.7796
R6771 XRX.XFRONT.XFE_E.SXN.n1 XRX.XFRONT.XFE_E.SXN.t0 5.73764
R6772 XRX.XFRONT.XFE_E.SXN.n24 XRX.XFRONT.XFE_E.SXN.t3 5.59012
R6773 XRX.XFRONT.XFE_E.SXN.n6 XRX.XFRONT.XFE_E.SXN.t9 5.54817
R6774 XRX.XFRONT.XFE_E.SXN.n23 XRX.XFRONT.XFE_E.SXN.n22 5.38537
R6775 XRX.XFRONT.XFE_E.SXN.n1 XRX.XFRONT.XFE_E.SXN.n0 5.32067
R6776 XRX.XFRONT.XFE_E.SXN.n3 XRX.XFRONT.XFE_E.SXN.n2 5.32067
R6777 XRX.XFRONT.XFE_E.SXN.n5 XRX.XFRONT.XFE_E.SXN.n4 5.32067
R6778 XRX.XFRONT.XFE_E.SXN.n11 XRX.XFRONT.XFE_E.SXN.n10 4.42851
R6779 XRX.XFRONT.XFE_E.SXN.n14 XRX.XFRONT.XFE_E.SXN.n13 4.42851
R6780 XRX.XFRONT.XFE_E.SXN XRX.XFRONT.XFE_E.SXN.n25 0.274413
R6781 XRX.XFRONT.XFE_E.SXN.n0 XRX.XFRONT.XFE_E.SXN.t6 0.228
R6782 XRX.XFRONT.XFE_E.SXN.n0 XRX.XFRONT.XFE_E.SXN.t1 0.228
R6783 XRX.XFRONT.XFE_E.SXN.n2 XRX.XFRONT.XFE_E.SXN.t4 0.228
R6784 XRX.XFRONT.XFE_E.SXN.n2 XRX.XFRONT.XFE_E.SXN.t7 0.228
R6785 XRX.XFRONT.XFE_E.SXN.n4 XRX.XFRONT.XFE_E.SXN.t8 0.228
R6786 XRX.XFRONT.XFE_E.SXN.n4 XRX.XFRONT.XFE_E.SXN.t5 0.228
R6787 XRX.XFRONT.XFE_E.SXN.n22 XRX.XFRONT.XFE_E.SXN.t2 0.20525
R6788 XRX.XFRONT.XFE_E.SXN.n22 XRX.XFRONT.XFE_E.SXN.t11 0.20525
R6789 XRX.XFRONT.XFE_E.SXN.n6 XRX.XFRONT.XFE_E.SXN.n5 0.189974
R6790 XRX.XFRONT.XFE_E.SXN.n5 XRX.XFRONT.XFE_E.SXN.n3 0.189974
R6791 XRX.XFRONT.XFE_E.SXN.n3 XRX.XFRONT.XFE_E.SXN.n1 0.189974
R6792 XRX.XFRONT.XFE_E.SXN.n24 XRX.XFRONT.XFE_E.SXN.n23 0.189974
R6793 XRX.XFRONT.XFE_E.SXN.n15 XRX.XFRONT.XFE_E.SXN.n8 0.1205
R6794 XRX.XFRONT.XFE_E.SXN.n19 XRX.XFRONT.XFE_E.SXN.n9 0.1205
R6795 XRX.XFRONT.XFE_E.SXN.n20 XRX.XFRONT.XFE_E.SXN.n8 0.0485
R6796 XRX.XFRONT.XFE_E.SXN.n20 XRX.XFRONT.XFE_E.SXN.n19 0.0485
R6797 XRX.XFRONT.XFE_E.BN.n25 XRX.XFRONT.XFE_E.BN.t15 113.632
R6798 XRX.XFRONT.XFE_E.BN.n11 XRX.XFRONT.XFE_E.BN.t23 113.632
R6799 XRX.XFRONT.XFE_E.BN.n15 XRX.XFRONT.XFE_E.BN.t16 113.632
R6800 XRX.XFRONT.XFE_E.BN.n26 XRX.XFRONT.XFE_E.BN.t14 109.174
R6801 XRX.XFRONT.XFE_E.BN.n27 XRX.XFRONT.XFE_E.BN.t13 109.174
R6802 XRX.XFRONT.XFE_E.BN.n28 XRX.XFRONT.XFE_E.BN.t12 109.174
R6803 XRX.XFRONT.XFE_E.BN.n29 XRX.XFRONT.XFE_E.BN.t11 109.174
R6804 XRX.XFRONT.XFE_E.BN.n30 XRX.XFRONT.XFE_E.BN.t10 109.174
R6805 XRX.XFRONT.XFE_E.BN.n18 XRX.XFRONT.XFE_E.BN.t19 109.174
R6806 XRX.XFRONT.XFE_E.BN.n19 XRX.XFRONT.XFE_E.BN.t20 109.174
R6807 XRX.XFRONT.XFE_E.BN.n12 XRX.XFRONT.XFE_E.BN.t22 109.174
R6808 XRX.XFRONT.XFE_E.BN.n13 XRX.XFRONT.XFE_E.BN.t21 109.174
R6809 XRX.XFRONT.XFE_E.BN.n17 XRX.XFRONT.XFE_E.BN.t18 109.174
R6810 XRX.XFRONT.XFE_E.BN.n14 XRX.XFRONT.XFE_E.BN.t17 109.174
R6811 XRX.XFRONT.XFE_E.BN.n27 XRX.XFRONT.XFE_E.BN.n24 18.4942
R6812 XRX.XFRONT.XFE_E.BN.n28 XRX.XFRONT.XFE_E.BN.n23 18.4942
R6813 XRX.XFRONT.XFE_E.BN.n29 XRX.XFRONT.XFE_E.BN.n22 18.4942
R6814 XRX.XFRONT.XFE_E.BN.n31 XRX.XFRONT.XFE_E.BN.n30 18.4942
R6815 XRX.XFRONT.XFE_E.BN.n18 XRX.XFRONT.XFE_E.BN.n9 18.4942
R6816 XRX.XFRONT.XFE_E.BN.n20 XRX.XFRONT.XFE_E.BN.n19 18.4942
R6817 XRX.XFRONT.XFE_E.BN.n13 XRX.XFRONT.XFE_E.BN.n10 18.4942
R6818 XRX.XFRONT.XFE_E.BN.n17 XRX.XFRONT.XFE_E.BN.n16 18.4942
R6819 XRX.XFRONT.XFE_E.BN.n32 XRX.XFRONT.XFE_E.BN.n31 15.5414
R6820 XRX.XFRONT.XFE_E.BN.n27 XRX.XFRONT.XFE_E.BN.n26 11.6805
R6821 XRX.XFRONT.XFE_E.BN.n28 XRX.XFRONT.XFE_E.BN.n27 11.6805
R6822 XRX.XFRONT.XFE_E.BN.n29 XRX.XFRONT.XFE_E.BN.n28 11.6805
R6823 XRX.XFRONT.XFE_E.BN.n30 XRX.XFRONT.XFE_E.BN.n29 11.6805
R6824 XRX.XFRONT.XFE_E.BN.n18 XRX.XFRONT.XFE_E.BN.n17 11.6805
R6825 XRX.XFRONT.XFE_E.BN.n19 XRX.XFRONT.XFE_E.BN.n18 11.6805
R6826 XRX.XFRONT.XFE_E.BN.n13 XRX.XFRONT.XFE_E.BN.n12 11.6805
R6827 XRX.XFRONT.XFE_E.BN.n19 XRX.XFRONT.XFE_E.BN.n13 11.6805
R6828 XRX.XFRONT.XFE_E.BN.n17 XRX.XFRONT.XFE_E.BN.n14 11.6805
R6829 XRX.XFRONT.XFE_E.BN.n32 XRX.XFRONT.XFE_E.BN.n21 9.87478
R6830 XRX.XFRONT.XFE_E.BN.n8 XRX.XFRONT.XFE_E.BN.n7 8.36407
R6831 XRX.XFRONT.XFE_E.BN.n8 XRX.XFRONT.XFE_E.BN.n0 7.91407
R6832 XRX.XFRONT.XFE_E.BN.n25 XRX.XFRONT.XFE_E.BN.n24 7.17687
R6833 XRX.XFRONT.XFE_E.BN.n16 XRX.XFRONT.XFE_E.BN.n15 7.17687
R6834 XRX.XFRONT.XFE_E.BN.n11 XRX.XFRONT.XFE_E.BN.n10 7.17687
R6835 XRX.XFRONT.XFE_E.BN XRX.XFRONT.XFE_E.BN.n32 6.37876
R6836 XRX.XFRONT.XFE_E.BN.n2 XRX.XFRONT.XFE_E.BN.t9 5.7796
R6837 XRX.XFRONT.XFE_E.BN.n4 XRX.XFRONT.XFE_E.BN.t2 5.7796
R6838 XRX.XFRONT.XFE_E.BN.n0 XRX.XFRONT.XFE_E.BN.t0 5.73764
R6839 XRX.XFRONT.XFE_E.BN.n0 XRX.XFRONT.XFE_E.BN.t1 5.54817
R6840 XRX.XFRONT.XFE_E.BN.n2 XRX.XFRONT.XFE_E.BN.n1 5.38537
R6841 XRX.XFRONT.XFE_E.BN.n6 XRX.XFRONT.XFE_E.BN.n5 5.38537
R6842 XRX.XFRONT.XFE_E.BN.n4 XRX.XFRONT.XFE_E.BN.n3 5.38537
R6843 XRX.XFRONT.XFE_E.BN XRX.XFRONT.XFE_E.BN.n8 4.53963
R6844 XRX.XFRONT.XFE_E.BN.n26 XRX.XFRONT.XFE_E.BN.n25 4.42851
R6845 XRX.XFRONT.XFE_E.BN.n12 XRX.XFRONT.XFE_E.BN.n11 4.42851
R6846 XRX.XFRONT.XFE_E.BN.n15 XRX.XFRONT.XFE_E.BN.n14 4.42851
R6847 XRX.XFRONT.XFE_E.BN.n1 XRX.XFRONT.XFE_E.BN.t7 0.20525
R6848 XRX.XFRONT.XFE_E.BN.n1 XRX.XFRONT.XFE_E.BN.t8 0.20525
R6849 XRX.XFRONT.XFE_E.BN.n5 XRX.XFRONT.XFE_E.BN.t5 0.20525
R6850 XRX.XFRONT.XFE_E.BN.n5 XRX.XFRONT.XFE_E.BN.t6 0.20525
R6851 XRX.XFRONT.XFE_E.BN.n3 XRX.XFRONT.XFE_E.BN.t3 0.20525
R6852 XRX.XFRONT.XFE_E.BN.n3 XRX.XFRONT.XFE_E.BN.t4 0.20525
R6853 XRX.XFRONT.XFE_E.BN.n6 XRX.XFRONT.XFE_E.BN.n4 0.189974
R6854 XRX.XFRONT.XFE_E.BN.n24 XRX.XFRONT.XFE_E.BN.n23 0.1205
R6855 XRX.XFRONT.XFE_E.BN.n23 XRX.XFRONT.XFE_E.BN.n22 0.1205
R6856 XRX.XFRONT.XFE_E.BN.n31 XRX.XFRONT.XFE_E.BN.n22 0.1205
R6857 XRX.XFRONT.XFE_E.BN.n16 XRX.XFRONT.XFE_E.BN.n9 0.1205
R6858 XRX.XFRONT.XFE_E.BN.n20 XRX.XFRONT.XFE_E.BN.n10 0.1205
R6859 XRX.XFRONT.XFE_E.BN.n7 XRX.XFRONT.XFE_E.BN.n6 0.0952368
R6860 XRX.XFRONT.XFE_E.BN.n7 XRX.XFRONT.XFE_E.BN.n2 0.0952368
R6861 XRX.XFRONT.XFE_E.BN.n21 XRX.XFRONT.XFE_E.BN.n9 0.0485
R6862 XRX.XFRONT.XFE_E.BN.n21 XRX.XFRONT.XFE_E.BN.n20 0.0485
R6863 XRX.XFRONT.XFE_O.NREGEN.n7 XRX.XFRONT.XFE_O.NREGEN.n0 18.0069
R6864 XRX.XFRONT.XFE_O.NREGEN.n29 XRX.XFRONT.XFE_O.NREGEN.n22 18.0069
R6865 XRX.XFRONT.XFE_O.NREGEN.n10 XRX.XFRONT.XFE_O.NREGEN.n9 10.6614
R6866 XRX.XFRONT.XFE_O.NREGEN.n21 XRX.XFRONT.XFE_O.NREGEN.n20 10.6614
R6867 XRX.XFRONT.XFE_O.NREGEN.n18 XRX.XFRONT.XFE_O.NREGEN.n17 9.32836
R6868 XRX.XFRONT.XFE_O.NREGEN.n7 XRX.XFRONT.XFE_O.NREGEN.n6 6.11407
R6869 XRX.XFRONT.XFE_O.NREGEN.n29 XRX.XFRONT.XFE_O.NREGEN.n28 6.11407
R6870 XRX.XFRONT.XFE_O.NREGEN.n10 XRX.XFRONT.XFE_O.NREGEN.n7 6.10485
R6871 XRX.XFRONT.XFE_O.NREGEN.n12 XRX.XFRONT.XFE_O.NREGEN.t30 5.7796
R6872 XRX.XFRONT.XFE_O.NREGEN.n16 XRX.XFRONT.XFE_O.NREGEN.t23 5.7796
R6873 XRX.XFRONT.XFE_O.NREGEN.n18 XRX.XFRONT.XFE_O.NREGEN.n10 5.75267
R6874 XRX.XFRONT.XFE_O.NREGEN.n0 XRX.XFRONT.XFE_O.NREGEN.t21 5.73764
R6875 XRX.XFRONT.XFE_O.NREGEN.n22 XRX.XFRONT.XFE_O.NREGEN.t19 5.73764
R6876 XRX.XFRONT.XFE_O.NREGEN.n9 XRX.XFRONT.XFE_O.NREGEN.t9 5.59012
R6877 XRX.XFRONT.XFE_O.NREGEN.n20 XRX.XFRONT.XFE_O.NREGEN.t11 5.59012
R6878 XRX.XFRONT.XFE_O.NREGEN.n9 XRX.XFRONT.XFE_O.NREGEN.n8 5.57485
R6879 XRX.XFRONT.XFE_O.NREGEN.n20 XRX.XFRONT.XFE_O.NREGEN.n19 5.57485
R6880 XRX.XFRONT.XFE_O.NREGEN.n6 XRX.XFRONT.XFE_O.NREGEN.n1 5.57485
R6881 XRX.XFRONT.XFE_O.NREGEN.n5 XRX.XFRONT.XFE_O.NREGEN.n3 5.57485
R6882 XRX.XFRONT.XFE_O.NREGEN.n28 XRX.XFRONT.XFE_O.NREGEN.n23 5.57485
R6883 XRX.XFRONT.XFE_O.NREGEN.n27 XRX.XFRONT.XFE_O.NREGEN.n25 5.57485
R6884 XRX.XFRONT.XFE_O.NREGEN.n0 XRX.XFRONT.XFE_O.NREGEN.t22 5.54817
R6885 XRX.XFRONT.XFE_O.NREGEN.n22 XRX.XFRONT.XFE_O.NREGEN.t20 5.54817
R6886 XRX.XFRONT.XFE_O.NREGEN.n6 XRX.XFRONT.XFE_O.NREGEN.n2 5.38537
R6887 XRX.XFRONT.XFE_O.NREGEN.n5 XRX.XFRONT.XFE_O.NREGEN.n4 5.38537
R6888 XRX.XFRONT.XFE_O.NREGEN.n28 XRX.XFRONT.XFE_O.NREGEN.n24 5.38537
R6889 XRX.XFRONT.XFE_O.NREGEN.n27 XRX.XFRONT.XFE_O.NREGEN.n26 5.38537
R6890 XRX.XFRONT.XFE_O.NREGEN.n12 XRX.XFRONT.XFE_O.NREGEN.n11 5.38537
R6891 XRX.XFRONT.XFE_O.NREGEN.n14 XRX.XFRONT.XFE_O.NREGEN.n13 5.38537
R6892 XRX.XFRONT.XFE_O.NREGEN.n16 XRX.XFRONT.XFE_O.NREGEN.n15 5.38537
R6893 XRX.XFRONT.XFE_O.NREGEN.n30 XRX.XFRONT.XFE_O.NREGEN.n29 4.5005
R6894 XRX.XFRONT.XFE_O.NREGEN.n21 XRX.XFRONT.XFE_O.NREGEN.n18 2.46572
R6895 XRX.XFRONT.XFE_O.NREGEN.n30 XRX.XFRONT.XFE_O.NREGEN.n21 1.91789
R6896 XRX.XFRONT.XFE_O.NREGEN.n8 XRX.XFRONT.XFE_O.NREGEN.t33 0.20525
R6897 XRX.XFRONT.XFE_O.NREGEN.n8 XRX.XFRONT.XFE_O.NREGEN.t10 0.20525
R6898 XRX.XFRONT.XFE_O.NREGEN.n19 XRX.XFRONT.XFE_O.NREGEN.t13 0.20525
R6899 XRX.XFRONT.XFE_O.NREGEN.n19 XRX.XFRONT.XFE_O.NREGEN.t12 0.20525
R6900 XRX.XFRONT.XFE_O.NREGEN.n1 XRX.XFRONT.XFE_O.NREGEN.t3 0.20525
R6901 XRX.XFRONT.XFE_O.NREGEN.n1 XRX.XFRONT.XFE_O.NREGEN.t7 0.20525
R6902 XRX.XFRONT.XFE_O.NREGEN.n2 XRX.XFRONT.XFE_O.NREGEN.t5 0.20525
R6903 XRX.XFRONT.XFE_O.NREGEN.n2 XRX.XFRONT.XFE_O.NREGEN.t31 0.20525
R6904 XRX.XFRONT.XFE_O.NREGEN.n4 XRX.XFRONT.XFE_O.NREGEN.t17 0.20525
R6905 XRX.XFRONT.XFE_O.NREGEN.n4 XRX.XFRONT.XFE_O.NREGEN.t15 0.20525
R6906 XRX.XFRONT.XFE_O.NREGEN.n3 XRX.XFRONT.XFE_O.NREGEN.t18 0.20525
R6907 XRX.XFRONT.XFE_O.NREGEN.n3 XRX.XFRONT.XFE_O.NREGEN.t1 0.20525
R6908 XRX.XFRONT.XFE_O.NREGEN.n23 XRX.XFRONT.XFE_O.NREGEN.t0 0.20525
R6909 XRX.XFRONT.XFE_O.NREGEN.n23 XRX.XFRONT.XFE_O.NREGEN.t8 0.20525
R6910 XRX.XFRONT.XFE_O.NREGEN.n24 XRX.XFRONT.XFE_O.NREGEN.t4 0.20525
R6911 XRX.XFRONT.XFE_O.NREGEN.n24 XRX.XFRONT.XFE_O.NREGEN.t32 0.20525
R6912 XRX.XFRONT.XFE_O.NREGEN.n26 XRX.XFRONT.XFE_O.NREGEN.t2 0.20525
R6913 XRX.XFRONT.XFE_O.NREGEN.n26 XRX.XFRONT.XFE_O.NREGEN.t6 0.20525
R6914 XRX.XFRONT.XFE_O.NREGEN.n25 XRX.XFRONT.XFE_O.NREGEN.t14 0.20525
R6915 XRX.XFRONT.XFE_O.NREGEN.n25 XRX.XFRONT.XFE_O.NREGEN.t16 0.20525
R6916 XRX.XFRONT.XFE_O.NREGEN.n11 XRX.XFRONT.XFE_O.NREGEN.t28 0.20525
R6917 XRX.XFRONT.XFE_O.NREGEN.n11 XRX.XFRONT.XFE_O.NREGEN.t29 0.20525
R6918 XRX.XFRONT.XFE_O.NREGEN.n13 XRX.XFRONT.XFE_O.NREGEN.t26 0.20525
R6919 XRX.XFRONT.XFE_O.NREGEN.n13 XRX.XFRONT.XFE_O.NREGEN.t27 0.20525
R6920 XRX.XFRONT.XFE_O.NREGEN.n15 XRX.XFRONT.XFE_O.NREGEN.t24 0.20525
R6921 XRX.XFRONT.XFE_O.NREGEN.n15 XRX.XFRONT.XFE_O.NREGEN.t25 0.20525
R6922 XRX.XFRONT.XFE_O.NREGEN.n14 XRX.XFRONT.XFE_O.NREGEN.n12 0.189974
R6923 XRX.XFRONT.XFE_O.NREGEN.n6 XRX.XFRONT.XFE_O.NREGEN.n5 0.189974
R6924 XRX.XFRONT.XFE_O.NREGEN.n28 XRX.XFRONT.XFE_O.NREGEN.n27 0.189974
R6925 XRX.XFRONT.XFE_O.NREGEN.n17 XRX.XFRONT.XFE_O.NREGEN.n16 0.0952368
R6926 XRX.XFRONT.XFE_O.NREGEN.n17 XRX.XFRONT.XFE_O.NREGEN.n14 0.0952368
R6927 XRX.XFRONT.XFE_O.NREGEN XRX.XFRONT.XFE_O.NREGEN.n30 0.0396304
R6928 XRX.XFRONT.XFE_E.NREGEN.n7 XRX.XFRONT.XFE_E.NREGEN.n0 18.0069
R6929 XRX.XFRONT.XFE_E.NREGEN.n15 XRX.XFRONT.XFE_E.NREGEN.n8 18.0069
R6930 XRX.XFRONT.XFE_E.NREGEN.n29 XRX.XFRONT.XFE_E.NREGEN.n28 10.6614
R6931 XRX.XFRONT.XFE_E.NREGEN.n18 XRX.XFRONT.XFE_E.NREGEN.n17 10.6614
R6932 XRX.XFRONT.XFE_E.NREGEN.n26 XRX.XFRONT.XFE_E.NREGEN.n25 9.32836
R6933 XRX.XFRONT.XFE_E.NREGEN.n7 XRX.XFRONT.XFE_E.NREGEN.n6 6.11407
R6934 XRX.XFRONT.XFE_E.NREGEN.n15 XRX.XFRONT.XFE_E.NREGEN.n14 6.11407
R6935 XRX.XFRONT.XFE_E.NREGEN.n18 XRX.XFRONT.XFE_E.NREGEN.n15 6.10485
R6936 XRX.XFRONT.XFE_E.NREGEN.n20 XRX.XFRONT.XFE_E.NREGEN.t24 5.7796
R6937 XRX.XFRONT.XFE_E.NREGEN.n22 XRX.XFRONT.XFE_E.NREGEN.t17 5.7796
R6938 XRX.XFRONT.XFE_E.NREGEN.n26 XRX.XFRONT.XFE_E.NREGEN.n18 5.75267
R6939 XRX.XFRONT.XFE_E.NREGEN.n0 XRX.XFRONT.XFE_E.NREGEN.t16 5.73764
R6940 XRX.XFRONT.XFE_E.NREGEN.n8 XRX.XFRONT.XFE_E.NREGEN.t14 5.73764
R6941 XRX.XFRONT.XFE_E.NREGEN.n28 XRX.XFRONT.XFE_E.NREGEN.t26 5.59012
R6942 XRX.XFRONT.XFE_E.NREGEN.n17 XRX.XFRONT.XFE_E.NREGEN.t29 5.59012
R6943 XRX.XFRONT.XFE_E.NREGEN.n28 XRX.XFRONT.XFE_E.NREGEN.n27 5.57485
R6944 XRX.XFRONT.XFE_E.NREGEN.n17 XRX.XFRONT.XFE_E.NREGEN.n16 5.57485
R6945 XRX.XFRONT.XFE_E.NREGEN.n3 XRX.XFRONT.XFE_E.NREGEN.n1 5.57485
R6946 XRX.XFRONT.XFE_E.NREGEN.n6 XRX.XFRONT.XFE_E.NREGEN.n5 5.57485
R6947 XRX.XFRONT.XFE_E.NREGEN.n11 XRX.XFRONT.XFE_E.NREGEN.n9 5.57485
R6948 XRX.XFRONT.XFE_E.NREGEN.n14 XRX.XFRONT.XFE_E.NREGEN.n13 5.57485
R6949 XRX.XFRONT.XFE_E.NREGEN.n0 XRX.XFRONT.XFE_E.NREGEN.t15 5.54817
R6950 XRX.XFRONT.XFE_E.NREGEN.n8 XRX.XFRONT.XFE_E.NREGEN.t13 5.54817
R6951 XRX.XFRONT.XFE_E.NREGEN.n3 XRX.XFRONT.XFE_E.NREGEN.n2 5.38537
R6952 XRX.XFRONT.XFE_E.NREGEN.n6 XRX.XFRONT.XFE_E.NREGEN.n4 5.38537
R6953 XRX.XFRONT.XFE_E.NREGEN.n11 XRX.XFRONT.XFE_E.NREGEN.n10 5.38537
R6954 XRX.XFRONT.XFE_E.NREGEN.n14 XRX.XFRONT.XFE_E.NREGEN.n12 5.38537
R6955 XRX.XFRONT.XFE_E.NREGEN.n20 XRX.XFRONT.XFE_E.NREGEN.n19 5.38537
R6956 XRX.XFRONT.XFE_E.NREGEN.n24 XRX.XFRONT.XFE_E.NREGEN.n23 5.38537
R6957 XRX.XFRONT.XFE_E.NREGEN.n22 XRX.XFRONT.XFE_E.NREGEN.n21 5.38537
R6958 XRX.XFRONT.XFE_E.NREGEN XRX.XFRONT.XFE_E.NREGEN.n7 4.53963
R6959 XRX.XFRONT.XFE_E.NREGEN.n29 XRX.XFRONT.XFE_E.NREGEN.n26 2.46572
R6960 XRX.XFRONT.XFE_E.NREGEN XRX.XFRONT.XFE_E.NREGEN.n29 1.87876
R6961 XRX.XFRONT.XFE_E.NREGEN.n27 XRX.XFRONT.XFE_E.NREGEN.t25 0.20525
R6962 XRX.XFRONT.XFE_E.NREGEN.n27 XRX.XFRONT.XFE_E.NREGEN.t11 0.20525
R6963 XRX.XFRONT.XFE_E.NREGEN.n16 XRX.XFRONT.XFE_E.NREGEN.t28 0.20525
R6964 XRX.XFRONT.XFE_E.NREGEN.n16 XRX.XFRONT.XFE_E.NREGEN.t27 0.20525
R6965 XRX.XFRONT.XFE_E.NREGEN.n1 XRX.XFRONT.XFE_E.NREGEN.t1 0.20525
R6966 XRX.XFRONT.XFE_E.NREGEN.n1 XRX.XFRONT.XFE_E.NREGEN.t6 0.20525
R6967 XRX.XFRONT.XFE_E.NREGEN.n2 XRX.XFRONT.XFE_E.NREGEN.t7 0.20525
R6968 XRX.XFRONT.XFE_E.NREGEN.n2 XRX.XFRONT.XFE_E.NREGEN.t30 0.20525
R6969 XRX.XFRONT.XFE_E.NREGEN.n4 XRX.XFRONT.XFE_E.NREGEN.t31 0.20525
R6970 XRX.XFRONT.XFE_E.NREGEN.n4 XRX.XFRONT.XFE_E.NREGEN.t9 0.20525
R6971 XRX.XFRONT.XFE_E.NREGEN.n5 XRX.XFRONT.XFE_E.NREGEN.t10 0.20525
R6972 XRX.XFRONT.XFE_E.NREGEN.n5 XRX.XFRONT.XFE_E.NREGEN.t8 0.20525
R6973 XRX.XFRONT.XFE_E.NREGEN.n9 XRX.XFRONT.XFE_E.NREGEN.t33 0.20525
R6974 XRX.XFRONT.XFE_E.NREGEN.n9 XRX.XFRONT.XFE_E.NREGEN.t12 0.20525
R6975 XRX.XFRONT.XFE_E.NREGEN.n10 XRX.XFRONT.XFE_E.NREGEN.t0 0.20525
R6976 XRX.XFRONT.XFE_E.NREGEN.n10 XRX.XFRONT.XFE_E.NREGEN.t5 0.20525
R6977 XRX.XFRONT.XFE_E.NREGEN.n12 XRX.XFRONT.XFE_E.NREGEN.t4 0.20525
R6978 XRX.XFRONT.XFE_E.NREGEN.n12 XRX.XFRONT.XFE_E.NREGEN.t32 0.20525
R6979 XRX.XFRONT.XFE_E.NREGEN.n13 XRX.XFRONT.XFE_E.NREGEN.t2 0.20525
R6980 XRX.XFRONT.XFE_E.NREGEN.n13 XRX.XFRONT.XFE_E.NREGEN.t3 0.20525
R6981 XRX.XFRONT.XFE_E.NREGEN.n19 XRX.XFRONT.XFE_E.NREGEN.t22 0.20525
R6982 XRX.XFRONT.XFE_E.NREGEN.n19 XRX.XFRONT.XFE_E.NREGEN.t23 0.20525
R6983 XRX.XFRONT.XFE_E.NREGEN.n23 XRX.XFRONT.XFE_E.NREGEN.t20 0.20525
R6984 XRX.XFRONT.XFE_E.NREGEN.n23 XRX.XFRONT.XFE_E.NREGEN.t21 0.20525
R6985 XRX.XFRONT.XFE_E.NREGEN.n21 XRX.XFRONT.XFE_E.NREGEN.t18 0.20525
R6986 XRX.XFRONT.XFE_E.NREGEN.n21 XRX.XFRONT.XFE_E.NREGEN.t19 0.20525
R6987 XRX.XFRONT.XFE_E.NREGEN.n24 XRX.XFRONT.XFE_E.NREGEN.n22 0.189974
R6988 XRX.XFRONT.XFE_E.NREGEN.n6 XRX.XFRONT.XFE_E.NREGEN.n3 0.189974
R6989 XRX.XFRONT.XFE_E.NREGEN.n14 XRX.XFRONT.XFE_E.NREGEN.n11 0.189974
R6990 XRX.XFRONT.XFE_E.NREGEN.n25 XRX.XFRONT.XFE_E.NREGEN.n24 0.0952368
R6991 XRX.XFRONT.XFE_E.NREGEN.n25 XRX.XFRONT.XFE_E.NREGEN.n20 0.0952368
R6992 XRX.XFRONT.XFE_O.XN.n70 XRX.XFRONT.XFE_O.XN.t57 127.788
R6993 XRX.XFRONT.XFE_O.XN.t50 XRX.XFRONT.XFE_O.XN.n60 127.788
R6994 XRX.XFRONT.XFE_O.XN.n67 XRX.XFRONT.XFE_O.XN.t53 127.668
R6995 XRX.XFRONT.XFE_O.XN.n70 XRX.XFRONT.XFE_O.XN.t56 127.668
R6996 XRX.XFRONT.XFE_O.XN.t55 XRX.XFRONT.XFE_O.XN.n71 127.668
R6997 XRX.XFRONT.XFE_O.XN.t54 XRX.XFRONT.XFE_O.XN.n68 127.668
R6998 XRX.XFRONT.XFE_O.XN.t51 XRX.XFRONT.XFE_O.XN.n60 127.668
R6999 XRX.XFRONT.XFE_O.XN.n66 XRX.XFRONT.XFE_O.XN.t52 127.668
R7000 XRX.XFRONT.XFE_O.XN.n22 XRX.XFRONT.XFE_O.XN.t41 113.632
R7001 XRX.XFRONT.XFE_O.XN.n5 XRX.XFRONT.XFE_O.XN.t49 113.632
R7002 XRX.XFRONT.XFE_O.XN.n76 XRX.XFRONT.XFE_O.XN.t37 113.632
R7003 XRX.XFRONT.XFE_O.XN.t57 XRX.XFRONT.XFE_O.XN.n57 113.632
R7004 XRX.XFRONT.XFE_O.XN.n63 XRX.XFRONT.XFE_O.XN.t50 113.632
R7005 XRX.XFRONT.XFE_O.XN.n23 XRX.XFRONT.XFE_O.XN.t40 109.174
R7006 XRX.XFRONT.XFE_O.XN.n24 XRX.XFRONT.XFE_O.XN.t39 109.174
R7007 XRX.XFRONT.XFE_O.XN.n25 XRX.XFRONT.XFE_O.XN.t38 109.174
R7008 XRX.XFRONT.XFE_O.XN.n0 XRX.XFRONT.XFE_O.XN.t42 109.174
R7009 XRX.XFRONT.XFE_O.XN.n11 XRX.XFRONT.XFE_O.XN.t43 109.174
R7010 XRX.XFRONT.XFE_O.XN.n10 XRX.XFRONT.XFE_O.XN.t44 109.174
R7011 XRX.XFRONT.XFE_O.XN.n6 XRX.XFRONT.XFE_O.XN.t48 109.174
R7012 XRX.XFRONT.XFE_O.XN.n7 XRX.XFRONT.XFE_O.XN.t47 109.174
R7013 XRX.XFRONT.XFE_O.XN.n8 XRX.XFRONT.XFE_O.XN.t46 109.174
R7014 XRX.XFRONT.XFE_O.XN.n9 XRX.XFRONT.XFE_O.XN.t45 109.174
R7015 XRX.XFRONT.XFE_O.XN.n77 XRX.XFRONT.XFE_O.XN.t36 109.174
R7016 XRX.XFRONT.XFE_O.XN.n78 XRX.XFRONT.XFE_O.XN.t35 109.174
R7017 XRX.XFRONT.XFE_O.XN.t53 XRX.XFRONT.XFE_O.XN.n59 109.174
R7018 XRX.XFRONT.XFE_O.XN.t56 XRX.XFRONT.XFE_O.XN.n58 109.174
R7019 XRX.XFRONT.XFE_O.XN.n72 XRX.XFRONT.XFE_O.XN.t55 109.174
R7020 XRX.XFRONT.XFE_O.XN.n69 XRX.XFRONT.XFE_O.XN.t54 109.174
R7021 XRX.XFRONT.XFE_O.XN.n64 XRX.XFRONT.XFE_O.XN.t51 109.174
R7022 XRX.XFRONT.XFE_O.XN.t52 XRX.XFRONT.XFE_O.XN.n65 109.174
R7023 XRX.XFRONT.XFE_O.XN.n46 XRX.XFRONT.XFE_O.XN.n45 21.0284
R7024 XRX.XFRONT.XFE_O.XN.n54 XRX.XFRONT.XFE_O.XN.n53 18.9712
R7025 XRX.XFRONT.XFE_O.XN.n13 XRX.XFRONT.XFE_O.XN.n0 18.5723
R7026 XRX.XFRONT.XFE_O.XN.n24 XRX.XFRONT.XFE_O.XN.n21 18.4942
R7027 XRX.XFRONT.XFE_O.XN.n26 XRX.XFRONT.XFE_O.XN.n25 18.4942
R7028 XRX.XFRONT.XFE_O.XN.n12 XRX.XFRONT.XFE_O.XN.n11 18.4942
R7029 XRX.XFRONT.XFE_O.XN.n10 XRX.XFRONT.XFE_O.XN.n1 18.4942
R7030 XRX.XFRONT.XFE_O.XN.n7 XRX.XFRONT.XFE_O.XN.n4 18.4942
R7031 XRX.XFRONT.XFE_O.XN.n8 XRX.XFRONT.XFE_O.XN.n3 18.4942
R7032 XRX.XFRONT.XFE_O.XN.n9 XRX.XFRONT.XFE_O.XN.n2 18.4942
R7033 XRX.XFRONT.XFE_O.XN.n79 XRX.XFRONT.XFE_O.XN.n78 18.4942
R7034 XRX.XFRONT.XFE_O.XN.n61 XRX.XFRONT.XFE_O.XN.n59 18.4942
R7035 XRX.XFRONT.XFE_O.XN.n73 XRX.XFRONT.XFE_O.XN.n72 18.4942
R7036 XRX.XFRONT.XFE_O.XN.n69 XRX.XFRONT.XFE_O.XN.n56 18.4942
R7037 XRX.XFRONT.XFE_O.XN.n65 XRX.XFRONT.XFE_O.XN.n62 18.4942
R7038 XRX.XFRONT.XFE_O.XN.n80 XRX.XFRONT.XFE_O.XN.n79 16.6599
R7039 XRX.XFRONT.XFE_O.XN.n38 XRX.XFRONT.XFE_O.XN.n35 12.6712
R7040 XRX.XFRONT.XFE_O.XN.n24 XRX.XFRONT.XFE_O.XN.n23 11.6805
R7041 XRX.XFRONT.XFE_O.XN.n25 XRX.XFRONT.XFE_O.XN.n24 11.6805
R7042 XRX.XFRONT.XFE_O.XN.n11 XRX.XFRONT.XFE_O.XN.n0 11.6805
R7043 XRX.XFRONT.XFE_O.XN.n11 XRX.XFRONT.XFE_O.XN.n10 11.6805
R7044 XRX.XFRONT.XFE_O.XN.n7 XRX.XFRONT.XFE_O.XN.n6 11.6805
R7045 XRX.XFRONT.XFE_O.XN.n8 XRX.XFRONT.XFE_O.XN.n7 11.6805
R7046 XRX.XFRONT.XFE_O.XN.n9 XRX.XFRONT.XFE_O.XN.n8 11.6805
R7047 XRX.XFRONT.XFE_O.XN.n10 XRX.XFRONT.XFE_O.XN.n9 11.6805
R7048 XRX.XFRONT.XFE_O.XN.n78 XRX.XFRONT.XFE_O.XN.n77 11.6805
R7049 XRX.XFRONT.XFE_O.XN.n72 XRX.XFRONT.XFE_O.XN.n69 11.6805
R7050 XRX.XFRONT.XFE_O.XN.n72 XRX.XFRONT.XFE_O.XN.n58 11.6805
R7051 XRX.XFRONT.XFE_O.XN.n69 XRX.XFRONT.XFE_O.XN.n59 11.6805
R7052 XRX.XFRONT.XFE_O.XN.n65 XRX.XFRONT.XFE_O.XN.n64 11.6805
R7053 XRX.XFRONT.XFE_O.XN.n65 XRX.XFRONT.XFE_O.XN.n59 11.6805
R7054 XRX.XFRONT.XFE_O.XN.n75 XRX.XFRONT.XFE_O.XN.n55 10.8396
R7055 XRX.XFRONT.XFE_O.XN.n28 XRX.XFRONT.XFE_O.XN.n13 10.7748
R7056 XRX.XFRONT.XFE_O.XN.n38 XRX.XFRONT.XFE_O.XN.n37 9.44001
R7057 XRX.XFRONT.XFE_O.XN.n27 XRX.XFRONT.XFE_O.XN.n26 9.1385
R7058 XRX.XFRONT.XFE_O.XN.n75 XRX.XFRONT.XFE_O.XN.n74 9.0005
R7059 XRX.XFRONT.XFE_O.XN.n22 XRX.XFRONT.XFE_O.XN.n21 7.17687
R7060 XRX.XFRONT.XFE_O.XN.n5 XRX.XFRONT.XFE_O.XN.n4 7.17687
R7061 XRX.XFRONT.XFE_O.XN.n79 XRX.XFRONT.XFE_O.XN.n76 7.17687
R7062 XRX.XFRONT.XFE_O.XN.n73 XRX.XFRONT.XFE_O.XN.n57 7.17687
R7063 XRX.XFRONT.XFE_O.XN.n63 XRX.XFRONT.XFE_O.XN.n62 7.17687
R7064 XRX.XFRONT.XFE_O.XN.n39 XRX.XFRONT.XFE_O.XN.n28 6.41789
R7065 XRX.XFRONT.XFE_O.XN.n27 XRX.XFRONT.XFE_O.XN.n20 6.40336
R7066 XRX.XFRONT.XFE_O.XN.n15 XRX.XFRONT.XFE_O.XN.t3 5.7796
R7067 XRX.XFRONT.XFE_O.XN.n19 XRX.XFRONT.XFE_O.XN.t15 5.7796
R7068 XRX.XFRONT.XFE_O.XN.n41 XRX.XFRONT.XFE_O.XN.t24 5.73764
R7069 XRX.XFRONT.XFE_O.XN.n30 XRX.XFRONT.XFE_O.XN.t16 5.73764
R7070 XRX.XFRONT.XFE_O.XN.n32 XRX.XFRONT.XFE_O.XN.t6 5.73764
R7071 XRX.XFRONT.XFE_O.XN.n45 XRX.XFRONT.XFE_O.XN.t17 5.73764
R7072 XRX.XFRONT.XFE_O.XN.n80 XRX.XFRONT.XFE_O.XN.n75 5.63193
R7073 XRX.XFRONT.XFE_O.XN.n37 XRX.XFRONT.XFE_O.XN.t34 5.59012
R7074 XRX.XFRONT.XFE_O.XN.n37 XRX.XFRONT.XFE_O.XN.n36 5.57485
R7075 XRX.XFRONT.XFE_O.XN.n50 XRX.XFRONT.XFE_O.XN.n48 5.51014
R7076 XRX.XFRONT.XFE_O.XN.n53 XRX.XFRONT.XFE_O.XN.n47 5.4154
R7077 XRX.XFRONT.XFE_O.XN.n15 XRX.XFRONT.XFE_O.XN.n14 5.38537
R7078 XRX.XFRONT.XFE_O.XN.n17 XRX.XFRONT.XFE_O.XN.n16 5.38537
R7079 XRX.XFRONT.XFE_O.XN.n19 XRX.XFRONT.XFE_O.XN.n18 5.38537
R7080 XRX.XFRONT.XFE_O.XN.n41 XRX.XFRONT.XFE_O.XN.n40 5.32067
R7081 XRX.XFRONT.XFE_O.XN.n43 XRX.XFRONT.XFE_O.XN.n42 5.32067
R7082 XRX.XFRONT.XFE_O.XN.n30 XRX.XFRONT.XFE_O.XN.n29 5.32067
R7083 XRX.XFRONT.XFE_O.XN.n34 XRX.XFRONT.XFE_O.XN.n33 5.32067
R7084 XRX.XFRONT.XFE_O.XN.n32 XRX.XFRONT.XFE_O.XN.n31 5.32067
R7085 XRX.XFRONT.XFE_O.XN.n52 XRX.XFRONT.XFE_O.XN.n51 5.32067
R7086 XRX.XFRONT.XFE_O.XN.n50 XRX.XFRONT.XFE_O.XN.n49 5.32067
R7087 XRX.XFRONT.XFE_O.XN.n45 XRX.XFRONT.XFE_O.XN.n44 5.32067
R7088 XRX.XFRONT.XFE_O.XN.n81 XRX.XFRONT.XFE_O.XN.n80 4.5005
R7089 XRX.XFRONT.XFE_O.XN.n39 XRX.XFRONT.XFE_O.XN.n38 4.5005
R7090 XRX.XFRONT.XFE_O.XN.n23 XRX.XFRONT.XFE_O.XN.n22 4.42851
R7091 XRX.XFRONT.XFE_O.XN.n6 XRX.XFRONT.XFE_O.XN.n5 4.42851
R7092 XRX.XFRONT.XFE_O.XN.n77 XRX.XFRONT.XFE_O.XN.n76 4.42851
R7093 XRX.XFRONT.XFE_O.XN.n58 XRX.XFRONT.XFE_O.XN.n57 4.42851
R7094 XRX.XFRONT.XFE_O.XN.n64 XRX.XFRONT.XFE_O.XN.n63 4.42851
R7095 XRX.XFRONT.XFE_O.XN.n81 XRX.XFRONT.XFE_O.XN.n54 3.95267
R7096 XRX.XFRONT.XFE_O.XN.n28 XRX.XFRONT.XFE_O.XN.n27 2.93193
R7097 XRX.XFRONT.XFE_O.XN.n46 XRX.XFRONT.XFE_O.XN.n39 1.76137
R7098 XRX.XFRONT.XFE_O.XN.n54 XRX.XFRONT.XFE_O.XN.n46 1.72224
R7099 XRX.XFRONT.XFE_O.XN.n40 XRX.XFRONT.XFE_O.XN.t22 0.228
R7100 XRX.XFRONT.XFE_O.XN.n40 XRX.XFRONT.XFE_O.XN.t23 0.228
R7101 XRX.XFRONT.XFE_O.XN.n42 XRX.XFRONT.XFE_O.XN.t20 0.228
R7102 XRX.XFRONT.XFE_O.XN.n42 XRX.XFRONT.XFE_O.XN.t21 0.228
R7103 XRX.XFRONT.XFE_O.XN.n29 XRX.XFRONT.XFE_O.XN.t12 0.228
R7104 XRX.XFRONT.XFE_O.XN.n29 XRX.XFRONT.XFE_O.XN.t11 0.228
R7105 XRX.XFRONT.XFE_O.XN.n33 XRX.XFRONT.XFE_O.XN.t10 0.228
R7106 XRX.XFRONT.XFE_O.XN.n33 XRX.XFRONT.XFE_O.XN.t9 0.228
R7107 XRX.XFRONT.XFE_O.XN.n31 XRX.XFRONT.XFE_O.XN.t8 0.228
R7108 XRX.XFRONT.XFE_O.XN.n31 XRX.XFRONT.XFE_O.XN.t7 0.228
R7109 XRX.XFRONT.XFE_O.XN.n47 XRX.XFRONT.XFE_O.XN.t31 0.228
R7110 XRX.XFRONT.XFE_O.XN.n47 XRX.XFRONT.XFE_O.XN.t32 0.228
R7111 XRX.XFRONT.XFE_O.XN.n51 XRX.XFRONT.XFE_O.XN.t29 0.228
R7112 XRX.XFRONT.XFE_O.XN.n51 XRX.XFRONT.XFE_O.XN.t30 0.228
R7113 XRX.XFRONT.XFE_O.XN.n49 XRX.XFRONT.XFE_O.XN.t27 0.228
R7114 XRX.XFRONT.XFE_O.XN.n49 XRX.XFRONT.XFE_O.XN.t28 0.228
R7115 XRX.XFRONT.XFE_O.XN.n48 XRX.XFRONT.XFE_O.XN.t25 0.228
R7116 XRX.XFRONT.XFE_O.XN.n48 XRX.XFRONT.XFE_O.XN.t26 0.228
R7117 XRX.XFRONT.XFE_O.XN.n44 XRX.XFRONT.XFE_O.XN.t18 0.228
R7118 XRX.XFRONT.XFE_O.XN.n44 XRX.XFRONT.XFE_O.XN.t19 0.228
R7119 XRX.XFRONT.XFE_O.XN.n14 XRX.XFRONT.XFE_O.XN.t33 0.20525
R7120 XRX.XFRONT.XFE_O.XN.n14 XRX.XFRONT.XFE_O.XN.t1 0.20525
R7121 XRX.XFRONT.XFE_O.XN.n16 XRX.XFRONT.XFE_O.XN.t13 0.20525
R7122 XRX.XFRONT.XFE_O.XN.n16 XRX.XFRONT.XFE_O.XN.t2 0.20525
R7123 XRX.XFRONT.XFE_O.XN.n18 XRX.XFRONT.XFE_O.XN.t0 0.20525
R7124 XRX.XFRONT.XFE_O.XN.n18 XRX.XFRONT.XFE_O.XN.t14 0.20525
R7125 XRX.XFRONT.XFE_O.XN.n36 XRX.XFRONT.XFE_O.XN.t5 0.20525
R7126 XRX.XFRONT.XFE_O.XN.n36 XRX.XFRONT.XFE_O.XN.t4 0.20525
R7127 XRX.XFRONT.XFE_O.XN.n45 XRX.XFRONT.XFE_O.XN.n43 0.189974
R7128 XRX.XFRONT.XFE_O.XN.n43 XRX.XFRONT.XFE_O.XN.n41 0.189974
R7129 XRX.XFRONT.XFE_O.XN.n17 XRX.XFRONT.XFE_O.XN.n15 0.189974
R7130 XRX.XFRONT.XFE_O.XN.n34 XRX.XFRONT.XFE_O.XN.n32 0.189974
R7131 XRX.XFRONT.XFE_O.XN.n52 XRX.XFRONT.XFE_O.XN.n50 0.189974
R7132 XRX.XFRONT.XFE_O.XN.n35 XRX.XFRONT.XFE_O.XN.n34 0.166289
R7133 XRX.XFRONT.XFE_O.XN.n26 XRX.XFRONT.XFE_O.XN.n21 0.1205
R7134 XRX.XFRONT.XFE_O.XN.n4 XRX.XFRONT.XFE_O.XN.n3 0.1205
R7135 XRX.XFRONT.XFE_O.XN.n3 XRX.XFRONT.XFE_O.XN.n2 0.1205
R7136 XRX.XFRONT.XFE_O.XN.n2 XRX.XFRONT.XFE_O.XN.n1 0.1205
R7137 XRX.XFRONT.XFE_O.XN.n62 XRX.XFRONT.XFE_O.XN.n61 0.1205
R7138 XRX.XFRONT.XFE_O.XN.n67 XRX.XFRONT.XFE_O.XN.n66 0.1205
R7139 XRX.XFRONT.XFE_O.XN.n66 XRX.XFRONT.XFE_O.XN.n60 0.1205
R7140 XRX.XFRONT.XFE_O.XN.n71 XRX.XFRONT.XFE_O.XN.n70 0.1205
R7141 XRX.XFRONT.XFE_O.XN.n12 XRX.XFRONT.XFE_O.XN.n1 0.114816
R7142 XRX.XFRONT.XFE_O.XN.n61 XRX.XFRONT.XFE_O.XN.n56 0.114816
R7143 XRX.XFRONT.XFE_O.XN.n68 XRX.XFRONT.XFE_O.XN.n67 0.114816
R7144 XRX.XFRONT.XFE_O.XN.n20 XRX.XFRONT.XFE_O.XN.n19 0.0952368
R7145 XRX.XFRONT.XFE_O.XN.n20 XRX.XFRONT.XFE_O.XN.n17 0.0952368
R7146 XRX.XFRONT.XFE_O.XN.n53 XRX.XFRONT.XFE_O.XN.n52 0.0952368
R7147 XRX.XFRONT.XFE_O.XN.n71 XRX.XFRONT.XFE_O.XN.n55 0.0785
R7148 XRX.XFRONT.XFE_O.XN.n74 XRX.XFRONT.XFE_O.XN.n73 0.0785
R7149 XRX.XFRONT.XFE_O.XN XRX.XFRONT.XFE_O.XN.n81 0.0396304
R7150 XRX.XFRONT.XFE_O.XN.n13 XRX.XFRONT.XFE_O.XN.n12 0.0241842
R7151 XRX.XFRONT.XFE_O.XN.n35 XRX.XFRONT.XFE_O.XN.n30 0.0241842
R7152 XRX.XFRONT.XFE_O.XN.n74 XRX.XFRONT.XFE_O.XN.n56 0.0241842
R7153 XRX.XFRONT.XFE_O.XN.n68 XRX.XFRONT.XFE_O.XN.n55 0.0241842
R7154 XRX.XFRONT.XFE_O.XP.n8 XRX.XFRONT.XFE_O.XP.t57 127.788
R7155 XRX.XFRONT.XFE_O.XP.t50 XRX.XFRONT.XFE_O.XP.n0 127.668
R7156 XRX.XFRONT.XFE_O.XP.t51 XRX.XFRONT.XFE_O.XP.n17 127.668
R7157 XRX.XFRONT.XFE_O.XP.n16 XRX.XFRONT.XFE_O.XP.t52 127.668
R7158 XRX.XFRONT.XFE_O.XP.n15 XRX.XFRONT.XFE_O.XP.t53 127.668
R7159 XRX.XFRONT.XFE_O.XP.t54 XRX.XFRONT.XFE_O.XP.n3 127.668
R7160 XRX.XFRONT.XFE_O.XP.t55 XRX.XFRONT.XFE_O.XP.n9 127.668
R7161 XRX.XFRONT.XFE_O.XP.n8 XRX.XFRONT.XFE_O.XP.t56 127.668
R7162 XRX.XFRONT.XFE_O.XP.n22 XRX.XFRONT.XFE_O.XP.t37 113.632
R7163 XRX.XFRONT.XFE_O.XP.t57 XRX.XFRONT.XFE_O.XP.n6 113.632
R7164 XRX.XFRONT.XFE_O.XP.n74 XRX.XFRONT.XFE_O.XP.t38 113.632
R7165 XRX.XFRONT.XFE_O.XP.n55 XRX.XFRONT.XFE_O.XP.t42 113.632
R7166 XRX.XFRONT.XFE_O.XP.n23 XRX.XFRONT.XFE_O.XP.t36 109.174
R7167 XRX.XFRONT.XFE_O.XP.n24 XRX.XFRONT.XFE_O.XP.t35 109.174
R7168 XRX.XFRONT.XFE_O.XP.n19 XRX.XFRONT.XFE_O.XP.t50 109.174
R7169 XRX.XFRONT.XFE_O.XP.n18 XRX.XFRONT.XFE_O.XP.t51 109.174
R7170 XRX.XFRONT.XFE_O.XP.t52 XRX.XFRONT.XFE_O.XP.n2 109.174
R7171 XRX.XFRONT.XFE_O.XP.t53 XRX.XFRONT.XFE_O.XP.n14 109.174
R7172 XRX.XFRONT.XFE_O.XP.n4 XRX.XFRONT.XFE_O.XP.t54 109.174
R7173 XRX.XFRONT.XFE_O.XP.n10 XRX.XFRONT.XFE_O.XP.t55 109.174
R7174 XRX.XFRONT.XFE_O.XP.t56 XRX.XFRONT.XFE_O.XP.n7 109.174
R7175 XRX.XFRONT.XFE_O.XP.n77 XRX.XFRONT.XFE_O.XP.t41 109.174
R7176 XRX.XFRONT.XFE_O.XP.n76 XRX.XFRONT.XFE_O.XP.t40 109.174
R7177 XRX.XFRONT.XFE_O.XP.n75 XRX.XFRONT.XFE_O.XP.t39 109.174
R7178 XRX.XFRONT.XFE_O.XP.n64 XRX.XFRONT.XFE_O.XP.t49 109.174
R7179 XRX.XFRONT.XFE_O.XP.n63 XRX.XFRONT.XFE_O.XP.t48 109.174
R7180 XRX.XFRONT.XFE_O.XP.n62 XRX.XFRONT.XFE_O.XP.t47 109.174
R7181 XRX.XFRONT.XFE_O.XP.n53 XRX.XFRONT.XFE_O.XP.t46 109.174
R7182 XRX.XFRONT.XFE_O.XP.n58 XRX.XFRONT.XFE_O.XP.t45 109.174
R7183 XRX.XFRONT.XFE_O.XP.n57 XRX.XFRONT.XFE_O.XP.t44 109.174
R7184 XRX.XFRONT.XFE_O.XP.n56 XRX.XFRONT.XFE_O.XP.t43 109.174
R7185 XRX.XFRONT.XFE_O.XP.n40 XRX.XFRONT.XFE_O.XP.n39 21.4784
R7186 XRX.XFRONT.XFE_O.XP.n33 XRX.XFRONT.XFE_O.XP.n32 21.4784
R7187 XRX.XFRONT.XFE_O.XP.n25 XRX.XFRONT.XFE_O.XP.n24 18.4942
R7188 XRX.XFRONT.XFE_O.XP.n20 XRX.XFRONT.XFE_O.XP.n19 18.4942
R7189 XRX.XFRONT.XFE_O.XP.n18 XRX.XFRONT.XFE_O.XP.n1 18.4942
R7190 XRX.XFRONT.XFE_O.XP.n5 XRX.XFRONT.XFE_O.XP.n2 18.4942
R7191 XRX.XFRONT.XFE_O.XP.n14 XRX.XFRONT.XFE_O.XP.n13 18.4942
R7192 XRX.XFRONT.XFE_O.XP.n12 XRX.XFRONT.XFE_O.XP.n4 18.4942
R7193 XRX.XFRONT.XFE_O.XP.n11 XRX.XFRONT.XFE_O.XP.n10 18.4942
R7194 XRX.XFRONT.XFE_O.XP.n78 XRX.XFRONT.XFE_O.XP.n77 18.4942
R7195 XRX.XFRONT.XFE_O.XP.n76 XRX.XFRONT.XFE_O.XP.n73 18.4942
R7196 XRX.XFRONT.XFE_O.XP.n65 XRX.XFRONT.XFE_O.XP.n64 18.4942
R7197 XRX.XFRONT.XFE_O.XP.n63 XRX.XFRONT.XFE_O.XP.n52 18.4942
R7198 XRX.XFRONT.XFE_O.XP.n62 XRX.XFRONT.XFE_O.XP.n61 18.4942
R7199 XRX.XFRONT.XFE_O.XP.n60 XRX.XFRONT.XFE_O.XP.n53 18.4942
R7200 XRX.XFRONT.XFE_O.XP.n59 XRX.XFRONT.XFE_O.XP.n58 18.4942
R7201 XRX.XFRONT.XFE_O.XP.n57 XRX.XFRONT.XFE_O.XP.n54 18.4942
R7202 XRX.XFRONT.XFE_O.XP.n26 XRX.XFRONT.XFE_O.XP.n25 16.2099
R7203 XRX.XFRONT.XFE_O.XP.n50 XRX.XFRONT.XFE_O.XP.n47 13.287
R7204 XRX.XFRONT.XFE_O.XP.n24 XRX.XFRONT.XFE_O.XP.n23 11.6805
R7205 XRX.XFRONT.XFE_O.XP.n19 XRX.XFRONT.XFE_O.XP.n18 11.6805
R7206 XRX.XFRONT.XFE_O.XP.n18 XRX.XFRONT.XFE_O.XP.n2 11.6805
R7207 XRX.XFRONT.XFE_O.XP.n14 XRX.XFRONT.XFE_O.XP.n2 11.6805
R7208 XRX.XFRONT.XFE_O.XP.n14 XRX.XFRONT.XFE_O.XP.n4 11.6805
R7209 XRX.XFRONT.XFE_O.XP.n10 XRX.XFRONT.XFE_O.XP.n4 11.6805
R7210 XRX.XFRONT.XFE_O.XP.n10 XRX.XFRONT.XFE_O.XP.n7 11.6805
R7211 XRX.XFRONT.XFE_O.XP.n77 XRX.XFRONT.XFE_O.XP.n76 11.6805
R7212 XRX.XFRONT.XFE_O.XP.n76 XRX.XFRONT.XFE_O.XP.n75 11.6805
R7213 XRX.XFRONT.XFE_O.XP.n64 XRX.XFRONT.XFE_O.XP.n63 11.6805
R7214 XRX.XFRONT.XFE_O.XP.n63 XRX.XFRONT.XFE_O.XP.n62 11.6805
R7215 XRX.XFRONT.XFE_O.XP.n62 XRX.XFRONT.XFE_O.XP.n53 11.6805
R7216 XRX.XFRONT.XFE_O.XP.n58 XRX.XFRONT.XFE_O.XP.n53 11.6805
R7217 XRX.XFRONT.XFE_O.XP.n58 XRX.XFRONT.XFE_O.XP.n57 11.6805
R7218 XRX.XFRONT.XFE_O.XP.n57 XRX.XFRONT.XFE_O.XP.n56 11.6805
R7219 XRX.XFRONT.XFE_O.XP.n80 XRX.XFRONT.XFE_O.XP.n65 11.3628
R7220 XRX.XFRONT.XFE_O.XP.n21 XRX.XFRONT.XFE_O.XP.n0 11.2176
R7221 XRX.XFRONT.XFE_O.XP.n33 XRX.XFRONT.XFE_O.XP.n26 9.3918
R7222 XRX.XFRONT.XFE_O.XP.n21 XRX.XFRONT.XFE_O.XP.n20 9.3785
R7223 XRX.XFRONT.XFE_O.XP.n79 XRX.XFRONT.XFE_O.XP.n78 9.3785
R7224 XRX.XFRONT.XFE_O.XP.n50 XRX.XFRONT.XFE_O.XP.n49 8.99001
R7225 XRX.XFRONT.XFE_O.XP.n25 XRX.XFRONT.XFE_O.XP.n22 7.17687
R7226 XRX.XFRONT.XFE_O.XP.n11 XRX.XFRONT.XFE_O.XP.n6 7.17687
R7227 XRX.XFRONT.XFE_O.XP.n74 XRX.XFRONT.XFE_O.XP.n73 7.17687
R7228 XRX.XFRONT.XFE_O.XP.n55 XRX.XFRONT.XFE_O.XP.n54 7.17687
R7229 XRX.XFRONT.XFE_O.XP.n79 XRX.XFRONT.XFE_O.XP.n72 6.40336
R7230 XRX.XFRONT.XFE_O.XP.n26 XRX.XFRONT.XFE_O.XP.n21 6.08193
R7231 XRX.XFRONT.XFE_O.XP.n67 XRX.XFRONT.XFE_O.XP.t4 5.7796
R7232 XRX.XFRONT.XFE_O.XP.n71 XRX.XFRONT.XFE_O.XP.t5 5.7796
R7233 XRX.XFRONT.XFE_O.XP.n39 XRX.XFRONT.XFE_O.XP.t14 5.73764
R7234 XRX.XFRONT.XFE_O.XP.n42 XRX.XFRONT.XFE_O.XP.t23 5.73764
R7235 XRX.XFRONT.XFE_O.XP.n28 XRX.XFRONT.XFE_O.XP.t22 5.73764
R7236 XRX.XFRONT.XFE_O.XP.n32 XRX.XFRONT.XFE_O.XP.t15 5.73764
R7237 XRX.XFRONT.XFE_O.XP.n35 XRX.XFRONT.XFE_O.XP.t7 5.73764
R7238 XRX.XFRONT.XFE_O.XP.n49 XRX.XFRONT.XFE_O.XP.t28 5.59012
R7239 XRX.XFRONT.XFE_O.XP.n49 XRX.XFRONT.XFE_O.XP.n48 5.57485
R7240 XRX.XFRONT.XFE_O.XP.n47 XRX.XFRONT.XFE_O.XP.t25 5.54817
R7241 XRX.XFRONT.XFE_O.XP.n67 XRX.XFRONT.XFE_O.XP.n66 5.38537
R7242 XRX.XFRONT.XFE_O.XP.n69 XRX.XFRONT.XFE_O.XP.n68 5.38537
R7243 XRX.XFRONT.XFE_O.XP.n71 XRX.XFRONT.XFE_O.XP.n70 5.38537
R7244 XRX.XFRONT.XFE_O.XP.n42 XRX.XFRONT.XFE_O.XP.n41 5.32067
R7245 XRX.XFRONT.XFE_O.XP.n44 XRX.XFRONT.XFE_O.XP.n43 5.32067
R7246 XRX.XFRONT.XFE_O.XP.n46 XRX.XFRONT.XFE_O.XP.n45 5.32067
R7247 XRX.XFRONT.XFE_O.XP.n28 XRX.XFRONT.XFE_O.XP.n27 5.32067
R7248 XRX.XFRONT.XFE_O.XP.n30 XRX.XFRONT.XFE_O.XP.n29 5.32067
R7249 XRX.XFRONT.XFE_O.XP.n32 XRX.XFRONT.XFE_O.XP.n31 5.32067
R7250 XRX.XFRONT.XFE_O.XP.n39 XRX.XFRONT.XFE_O.XP.n38 5.32067
R7251 XRX.XFRONT.XFE_O.XP.n37 XRX.XFRONT.XFE_O.XP.n36 5.32067
R7252 XRX.XFRONT.XFE_O.XP.n35 XRX.XFRONT.XFE_O.XP.n34 5.32067
R7253 XRX.XFRONT.XFE_O.XP.n51 XRX.XFRONT.XFE_O.XP.n50 4.5005
R7254 XRX.XFRONT.XFE_O.XP.n81 XRX.XFRONT.XFE_O.XP.n80 4.5005
R7255 XRX.XFRONT.XFE_O.XP.n23 XRX.XFRONT.XFE_O.XP.n22 4.42851
R7256 XRX.XFRONT.XFE_O.XP.n7 XRX.XFRONT.XFE_O.XP.n6 4.42851
R7257 XRX.XFRONT.XFE_O.XP.n75 XRX.XFRONT.XFE_O.XP.n74 4.42851
R7258 XRX.XFRONT.XFE_O.XP.n56 XRX.XFRONT.XFE_O.XP.n55 4.42851
R7259 XRX.XFRONT.XFE_O.XP.n80 XRX.XFRONT.XFE_O.XP.n79 2.48193
R7260 XRX.XFRONT.XFE_O.XP.n51 XRX.XFRONT.XFE_O.XP.n40 2.38746
R7261 XRX.XFRONT.XFE_O.XP.n40 XRX.XFRONT.XFE_O.XP.n33 1.72224
R7262 XRX.XFRONT.XFE_O.XP.n81 XRX.XFRONT.XFE_O.XP.n51 1.60485
R7263 XRX.XFRONT.XFE_O.XP.n41 XRX.XFRONT.XFE_O.XP.t27 0.228
R7264 XRX.XFRONT.XFE_O.XP.n41 XRX.XFRONT.XFE_O.XP.t24 0.228
R7265 XRX.XFRONT.XFE_O.XP.n43 XRX.XFRONT.XFE_O.XP.t33 0.228
R7266 XRX.XFRONT.XFE_O.XP.n43 XRX.XFRONT.XFE_O.XP.t26 0.228
R7267 XRX.XFRONT.XFE_O.XP.n45 XRX.XFRONT.XFE_O.XP.t31 0.228
R7268 XRX.XFRONT.XFE_O.XP.n45 XRX.XFRONT.XFE_O.XP.t32 0.228
R7269 XRX.XFRONT.XFE_O.XP.n27 XRX.XFRONT.XFE_O.XP.t20 0.228
R7270 XRX.XFRONT.XFE_O.XP.n27 XRX.XFRONT.XFE_O.XP.t21 0.228
R7271 XRX.XFRONT.XFE_O.XP.n29 XRX.XFRONT.XFE_O.XP.t18 0.228
R7272 XRX.XFRONT.XFE_O.XP.n29 XRX.XFRONT.XFE_O.XP.t19 0.228
R7273 XRX.XFRONT.XFE_O.XP.n31 XRX.XFRONT.XFE_O.XP.t16 0.228
R7274 XRX.XFRONT.XFE_O.XP.n31 XRX.XFRONT.XFE_O.XP.t17 0.228
R7275 XRX.XFRONT.XFE_O.XP.n38 XRX.XFRONT.XFE_O.XP.t12 0.228
R7276 XRX.XFRONT.XFE_O.XP.n38 XRX.XFRONT.XFE_O.XP.t13 0.228
R7277 XRX.XFRONT.XFE_O.XP.n36 XRX.XFRONT.XFE_O.XP.t10 0.228
R7278 XRX.XFRONT.XFE_O.XP.n36 XRX.XFRONT.XFE_O.XP.t11 0.228
R7279 XRX.XFRONT.XFE_O.XP.n34 XRX.XFRONT.XFE_O.XP.t8 0.228
R7280 XRX.XFRONT.XFE_O.XP.n34 XRX.XFRONT.XFE_O.XP.t9 0.228
R7281 XRX.XFRONT.XFE_O.XP.n66 XRX.XFRONT.XFE_O.XP.t34 0.20525
R7282 XRX.XFRONT.XFE_O.XP.n66 XRX.XFRONT.XFE_O.XP.t0 0.20525
R7283 XRX.XFRONT.XFE_O.XP.n68 XRX.XFRONT.XFE_O.XP.t3 0.20525
R7284 XRX.XFRONT.XFE_O.XP.n68 XRX.XFRONT.XFE_O.XP.t2 0.20525
R7285 XRX.XFRONT.XFE_O.XP.n70 XRX.XFRONT.XFE_O.XP.t6 0.20525
R7286 XRX.XFRONT.XFE_O.XP.n70 XRX.XFRONT.XFE_O.XP.t1 0.20525
R7287 XRX.XFRONT.XFE_O.XP.n48 XRX.XFRONT.XFE_O.XP.t29 0.20525
R7288 XRX.XFRONT.XFE_O.XP.n48 XRX.XFRONT.XFE_O.XP.t30 0.20525
R7289 XRX.XFRONT.XFE_O.XP.n37 XRX.XFRONT.XFE_O.XP.n35 0.189974
R7290 XRX.XFRONT.XFE_O.XP.n39 XRX.XFRONT.XFE_O.XP.n37 0.189974
R7291 XRX.XFRONT.XFE_O.XP.n69 XRX.XFRONT.XFE_O.XP.n67 0.189974
R7292 XRX.XFRONT.XFE_O.XP.n47 XRX.XFRONT.XFE_O.XP.n46 0.189974
R7293 XRX.XFRONT.XFE_O.XP.n46 XRX.XFRONT.XFE_O.XP.n44 0.189974
R7294 XRX.XFRONT.XFE_O.XP.n44 XRX.XFRONT.XFE_O.XP.n42 0.189974
R7295 XRX.XFRONT.XFE_O.XP.n32 XRX.XFRONT.XFE_O.XP.n30 0.189974
R7296 XRX.XFRONT.XFE_O.XP.n30 XRX.XFRONT.XFE_O.XP.n28 0.189974
R7297 XRX.XFRONT.XFE_O.XP.n12 XRX.XFRONT.XFE_O.XP.n11 0.1205
R7298 XRX.XFRONT.XFE_O.XP.n13 XRX.XFRONT.XFE_O.XP.n12 0.1205
R7299 XRX.XFRONT.XFE_O.XP.n13 XRX.XFRONT.XFE_O.XP.n5 0.1205
R7300 XRX.XFRONT.XFE_O.XP.n5 XRX.XFRONT.XFE_O.XP.n1 0.1205
R7301 XRX.XFRONT.XFE_O.XP.n20 XRX.XFRONT.XFE_O.XP.n1 0.1205
R7302 XRX.XFRONT.XFE_O.XP.n9 XRX.XFRONT.XFE_O.XP.n8 0.1205
R7303 XRX.XFRONT.XFE_O.XP.n9 XRX.XFRONT.XFE_O.XP.n3 0.1205
R7304 XRX.XFRONT.XFE_O.XP.n15 XRX.XFRONT.XFE_O.XP.n3 0.1205
R7305 XRX.XFRONT.XFE_O.XP.n16 XRX.XFRONT.XFE_O.XP.n15 0.1205
R7306 XRX.XFRONT.XFE_O.XP.n17 XRX.XFRONT.XFE_O.XP.n16 0.1205
R7307 XRX.XFRONT.XFE_O.XP.n17 XRX.XFRONT.XFE_O.XP.n0 0.1205
R7308 XRX.XFRONT.XFE_O.XP.n78 XRX.XFRONT.XFE_O.XP.n73 0.1205
R7309 XRX.XFRONT.XFE_O.XP.n65 XRX.XFRONT.XFE_O.XP.n52 0.1205
R7310 XRX.XFRONT.XFE_O.XP.n61 XRX.XFRONT.XFE_O.XP.n52 0.1205
R7311 XRX.XFRONT.XFE_O.XP.n61 XRX.XFRONT.XFE_O.XP.n60 0.1205
R7312 XRX.XFRONT.XFE_O.XP.n60 XRX.XFRONT.XFE_O.XP.n59 0.1205
R7313 XRX.XFRONT.XFE_O.XP.n59 XRX.XFRONT.XFE_O.XP.n54 0.1205
R7314 XRX.XFRONT.XFE_O.XP.n72 XRX.XFRONT.XFE_O.XP.n71 0.0952368
R7315 XRX.XFRONT.XFE_O.XP.n72 XRX.XFRONT.XFE_O.XP.n69 0.0952368
R7316 XRX.XFRONT.XFE_O.XP XRX.XFRONT.XFE_O.XP.n81 0.0396304
R7317 XRX.XFRONT.XFE_E.XP.t50 XRX.XFRONT.XFE_E.XP.n40 127.788
R7318 XRX.XFRONT.XFE_E.XP.t57 XRX.XFRONT.XFE_E.XP.n29 127.668
R7319 XRX.XFRONT.XFE_E.XP.n40 XRX.XFRONT.XFE_E.XP.t51 127.668
R7320 XRX.XFRONT.XFE_E.XP.n39 XRX.XFRONT.XFE_E.XP.t52 127.668
R7321 XRX.XFRONT.XFE_E.XP.n38 XRX.XFRONT.XFE_E.XP.t53 127.668
R7322 XRX.XFRONT.XFE_E.XP.n37 XRX.XFRONT.XFE_E.XP.t54 127.668
R7323 XRX.XFRONT.XFE_E.XP.n36 XRX.XFRONT.XFE_E.XP.t55 127.668
R7324 XRX.XFRONT.XFE_E.XP.n35 XRX.XFRONT.XFE_E.XP.t56 127.668
R7325 XRX.XFRONT.XFE_E.XP.n22 XRX.XFRONT.XFE_E.XP.t41 113.632
R7326 XRX.XFRONT.XFE_E.XP.n5 XRX.XFRONT.XFE_E.XP.t49 113.632
R7327 XRX.XFRONT.XFE_E.XP.n51 XRX.XFRONT.XFE_E.XP.t35 113.632
R7328 XRX.XFRONT.XFE_E.XP.n41 XRX.XFRONT.XFE_E.XP.t50 113.632
R7329 XRX.XFRONT.XFE_E.XP.n23 XRX.XFRONT.XFE_E.XP.t40 109.174
R7330 XRX.XFRONT.XFE_E.XP.n24 XRX.XFRONT.XFE_E.XP.t39 109.174
R7331 XRX.XFRONT.XFE_E.XP.n25 XRX.XFRONT.XFE_E.XP.t38 109.174
R7332 XRX.XFRONT.XFE_E.XP.n6 XRX.XFRONT.XFE_E.XP.t48 109.174
R7333 XRX.XFRONT.XFE_E.XP.n7 XRX.XFRONT.XFE_E.XP.t47 109.174
R7334 XRX.XFRONT.XFE_E.XP.n8 XRX.XFRONT.XFE_E.XP.t46 109.174
R7335 XRX.XFRONT.XFE_E.XP.n9 XRX.XFRONT.XFE_E.XP.t45 109.174
R7336 XRX.XFRONT.XFE_E.XP.n10 XRX.XFRONT.XFE_E.XP.t44 109.174
R7337 XRX.XFRONT.XFE_E.XP.n11 XRX.XFRONT.XFE_E.XP.t43 109.174
R7338 XRX.XFRONT.XFE_E.XP.n12 XRX.XFRONT.XFE_E.XP.t42 109.174
R7339 XRX.XFRONT.XFE_E.XP.n53 XRX.XFRONT.XFE_E.XP.t37 109.174
R7340 XRX.XFRONT.XFE_E.XP.n52 XRX.XFRONT.XFE_E.XP.t36 109.174
R7341 XRX.XFRONT.XFE_E.XP.n48 XRX.XFRONT.XFE_E.XP.t57 109.174
R7342 XRX.XFRONT.XFE_E.XP.n42 XRX.XFRONT.XFE_E.XP.t51 109.174
R7343 XRX.XFRONT.XFE_E.XP.n43 XRX.XFRONT.XFE_E.XP.t52 109.174
R7344 XRX.XFRONT.XFE_E.XP.n44 XRX.XFRONT.XFE_E.XP.t53 109.174
R7345 XRX.XFRONT.XFE_E.XP.n45 XRX.XFRONT.XFE_E.XP.t54 109.174
R7346 XRX.XFRONT.XFE_E.XP.n46 XRX.XFRONT.XFE_E.XP.t55 109.174
R7347 XRX.XFRONT.XFE_E.XP.n47 XRX.XFRONT.XFE_E.XP.t56 109.174
R7348 XRX.XFRONT.XFE_E.XP.n69 XRX.XFRONT.XFE_E.XP.n68 21.4784
R7349 XRX.XFRONT.XFE_E.XP.n62 XRX.XFRONT.XFE_E.XP.n61 21.4784
R7350 XRX.XFRONT.XFE_E.XP.n24 XRX.XFRONT.XFE_E.XP.n21 18.4942
R7351 XRX.XFRONT.XFE_E.XP.n26 XRX.XFRONT.XFE_E.XP.n25 18.4942
R7352 XRX.XFRONT.XFE_E.XP.n7 XRX.XFRONT.XFE_E.XP.n4 18.4942
R7353 XRX.XFRONT.XFE_E.XP.n8 XRX.XFRONT.XFE_E.XP.n3 18.4942
R7354 XRX.XFRONT.XFE_E.XP.n9 XRX.XFRONT.XFE_E.XP.n2 18.4942
R7355 XRX.XFRONT.XFE_E.XP.n10 XRX.XFRONT.XFE_E.XP.n1 18.4942
R7356 XRX.XFRONT.XFE_E.XP.n11 XRX.XFRONT.XFE_E.XP.n0 18.4942
R7357 XRX.XFRONT.XFE_E.XP.n13 XRX.XFRONT.XFE_E.XP.n12 18.4942
R7358 XRX.XFRONT.XFE_E.XP.n54 XRX.XFRONT.XFE_E.XP.n53 18.4942
R7359 XRX.XFRONT.XFE_E.XP.n49 XRX.XFRONT.XFE_E.XP.n48 18.4942
R7360 XRX.XFRONT.XFE_E.XP.n43 XRX.XFRONT.XFE_E.XP.n34 18.4942
R7361 XRX.XFRONT.XFE_E.XP.n44 XRX.XFRONT.XFE_E.XP.n33 18.4942
R7362 XRX.XFRONT.XFE_E.XP.n45 XRX.XFRONT.XFE_E.XP.n32 18.4942
R7363 XRX.XFRONT.XFE_E.XP.n46 XRX.XFRONT.XFE_E.XP.n31 18.4942
R7364 XRX.XFRONT.XFE_E.XP.n47 XRX.XFRONT.XFE_E.XP.n30 18.4942
R7365 XRX.XFRONT.XFE_E.XP.n55 XRX.XFRONT.XFE_E.XP.n54 16.2099
R7366 XRX.XFRONT.XFE_E.XP.n79 XRX.XFRONT.XFE_E.XP.n76 13.287
R7367 XRX.XFRONT.XFE_E.XP.n24 XRX.XFRONT.XFE_E.XP.n23 11.6805
R7368 XRX.XFRONT.XFE_E.XP.n25 XRX.XFRONT.XFE_E.XP.n24 11.6805
R7369 XRX.XFRONT.XFE_E.XP.n7 XRX.XFRONT.XFE_E.XP.n6 11.6805
R7370 XRX.XFRONT.XFE_E.XP.n8 XRX.XFRONT.XFE_E.XP.n7 11.6805
R7371 XRX.XFRONT.XFE_E.XP.n9 XRX.XFRONT.XFE_E.XP.n8 11.6805
R7372 XRX.XFRONT.XFE_E.XP.n10 XRX.XFRONT.XFE_E.XP.n9 11.6805
R7373 XRX.XFRONT.XFE_E.XP.n11 XRX.XFRONT.XFE_E.XP.n10 11.6805
R7374 XRX.XFRONT.XFE_E.XP.n12 XRX.XFRONT.XFE_E.XP.n11 11.6805
R7375 XRX.XFRONT.XFE_E.XP.n53 XRX.XFRONT.XFE_E.XP.n52 11.6805
R7376 XRX.XFRONT.XFE_E.XP.n43 XRX.XFRONT.XFE_E.XP.n42 11.6805
R7377 XRX.XFRONT.XFE_E.XP.n44 XRX.XFRONT.XFE_E.XP.n43 11.6805
R7378 XRX.XFRONT.XFE_E.XP.n45 XRX.XFRONT.XFE_E.XP.n44 11.6805
R7379 XRX.XFRONT.XFE_E.XP.n46 XRX.XFRONT.XFE_E.XP.n45 11.6805
R7380 XRX.XFRONT.XFE_E.XP.n47 XRX.XFRONT.XFE_E.XP.n46 11.6805
R7381 XRX.XFRONT.XFE_E.XP.n48 XRX.XFRONT.XFE_E.XP.n47 11.6805
R7382 XRX.XFRONT.XFE_E.XP.n28 XRX.XFRONT.XFE_E.XP.n13 11.3628
R7383 XRX.XFRONT.XFE_E.XP.n50 XRX.XFRONT.XFE_E.XP.n29 11.2176
R7384 XRX.XFRONT.XFE_E.XP.n62 XRX.XFRONT.XFE_E.XP.n55 9.3918
R7385 XRX.XFRONT.XFE_E.XP.n27 XRX.XFRONT.XFE_E.XP.n26 9.3785
R7386 XRX.XFRONT.XFE_E.XP.n50 XRX.XFRONT.XFE_E.XP.n49 9.3785
R7387 XRX.XFRONT.XFE_E.XP.n79 XRX.XFRONT.XFE_E.XP.n78 8.99001
R7388 XRX.XFRONT.XFE_E.XP.n22 XRX.XFRONT.XFE_E.XP.n21 7.17687
R7389 XRX.XFRONT.XFE_E.XP.n5 XRX.XFRONT.XFE_E.XP.n4 7.17687
R7390 XRX.XFRONT.XFE_E.XP.n54 XRX.XFRONT.XFE_E.XP.n51 7.17687
R7391 XRX.XFRONT.XFE_E.XP.n41 XRX.XFRONT.XFE_E.XP.n34 7.17687
R7392 XRX.XFRONT.XFE_E.XP.n27 XRX.XFRONT.XFE_E.XP.n20 6.40336
R7393 XRX.XFRONT.XFE_E.XP.n55 XRX.XFRONT.XFE_E.XP.n50 6.08193
R7394 XRX.XFRONT.XFE_E.XP.n15 XRX.XFRONT.XFE_E.XP.t1 5.7796
R7395 XRX.XFRONT.XFE_E.XP.n17 XRX.XFRONT.XFE_E.XP.t5 5.7796
R7396 XRX.XFRONT.XFE_E.XP.n64 XRX.XFRONT.XFE_E.XP.t14 5.73764
R7397 XRX.XFRONT.XFE_E.XP.n71 XRX.XFRONT.XFE_E.XP.t32 5.73764
R7398 XRX.XFRONT.XFE_E.XP.n61 XRX.XFRONT.XFE_E.XP.t17 5.73764
R7399 XRX.XFRONT.XFE_E.XP.n58 XRX.XFRONT.XFE_E.XP.t18 5.73764
R7400 XRX.XFRONT.XFE_E.XP.n68 XRX.XFRONT.XFE_E.XP.t7 5.73764
R7401 XRX.XFRONT.XFE_E.XP.n78 XRX.XFRONT.XFE_E.XP.t6 5.59012
R7402 XRX.XFRONT.XFE_E.XP.n78 XRX.XFRONT.XFE_E.XP.n77 5.57485
R7403 XRX.XFRONT.XFE_E.XP.n76 XRX.XFRONT.XFE_E.XP.t23 5.54817
R7404 XRX.XFRONT.XFE_E.XP.n15 XRX.XFRONT.XFE_E.XP.n14 5.38537
R7405 XRX.XFRONT.XFE_E.XP.n19 XRX.XFRONT.XFE_E.XP.n18 5.38537
R7406 XRX.XFRONT.XFE_E.XP.n17 XRX.XFRONT.XFE_E.XP.n16 5.38537
R7407 XRX.XFRONT.XFE_E.XP.n64 XRX.XFRONT.XFE_E.XP.n63 5.32067
R7408 XRX.XFRONT.XFE_E.XP.n66 XRX.XFRONT.XFE_E.XP.n65 5.32067
R7409 XRX.XFRONT.XFE_E.XP.n75 XRX.XFRONT.XFE_E.XP.n74 5.32067
R7410 XRX.XFRONT.XFE_E.XP.n73 XRX.XFRONT.XFE_E.XP.n72 5.32067
R7411 XRX.XFRONT.XFE_E.XP.n71 XRX.XFRONT.XFE_E.XP.n70 5.32067
R7412 XRX.XFRONT.XFE_E.XP.n61 XRX.XFRONT.XFE_E.XP.n56 5.32067
R7413 XRX.XFRONT.XFE_E.XP.n60 XRX.XFRONT.XFE_E.XP.n59 5.32067
R7414 XRX.XFRONT.XFE_E.XP.n58 XRX.XFRONT.XFE_E.XP.n57 5.32067
R7415 XRX.XFRONT.XFE_E.XP.n68 XRX.XFRONT.XFE_E.XP.n67 5.32067
R7416 XRX.XFRONT.XFE_E.XP XRX.XFRONT.XFE_E.XP.n28 4.53963
R7417 XRX.XFRONT.XFE_E.XP.n80 XRX.XFRONT.XFE_E.XP.n79 4.5005
R7418 XRX.XFRONT.XFE_E.XP.n23 XRX.XFRONT.XFE_E.XP.n22 4.42851
R7419 XRX.XFRONT.XFE_E.XP.n6 XRX.XFRONT.XFE_E.XP.n5 4.42851
R7420 XRX.XFRONT.XFE_E.XP.n52 XRX.XFRONT.XFE_E.XP.n51 4.42851
R7421 XRX.XFRONT.XFE_E.XP.n42 XRX.XFRONT.XFE_E.XP.n41 4.42851
R7422 XRX.XFRONT.XFE_E.XP.n28 XRX.XFRONT.XFE_E.XP.n27 2.48193
R7423 XRX.XFRONT.XFE_E.XP.n80 XRX.XFRONT.XFE_E.XP.n69 2.38746
R7424 XRX.XFRONT.XFE_E.XP.n69 XRX.XFRONT.XFE_E.XP.n62 1.72224
R7425 XRX.XFRONT.XFE_E.XP XRX.XFRONT.XFE_E.XP.n80 1.56572
R7426 XRX.XFRONT.XFE_E.XP.n63 XRX.XFRONT.XFE_E.XP.t12 0.228
R7427 XRX.XFRONT.XFE_E.XP.n63 XRX.XFRONT.XFE_E.XP.t13 0.228
R7428 XRX.XFRONT.XFE_E.XP.n65 XRX.XFRONT.XFE_E.XP.t10 0.228
R7429 XRX.XFRONT.XFE_E.XP.n65 XRX.XFRONT.XFE_E.XP.t11 0.228
R7430 XRX.XFRONT.XFE_E.XP.n74 XRX.XFRONT.XFE_E.XP.t25 0.228
R7431 XRX.XFRONT.XFE_E.XP.n74 XRX.XFRONT.XFE_E.XP.t24 0.228
R7432 XRX.XFRONT.XFE_E.XP.n72 XRX.XFRONT.XFE_E.XP.t33 0.228
R7433 XRX.XFRONT.XFE_E.XP.n72 XRX.XFRONT.XFE_E.XP.t26 0.228
R7434 XRX.XFRONT.XFE_E.XP.n70 XRX.XFRONT.XFE_E.XP.t31 0.228
R7435 XRX.XFRONT.XFE_E.XP.n70 XRX.XFRONT.XFE_E.XP.t34 0.228
R7436 XRX.XFRONT.XFE_E.XP.n56 XRX.XFRONT.XFE_E.XP.t15 0.228
R7437 XRX.XFRONT.XFE_E.XP.n56 XRX.XFRONT.XFE_E.XP.t16 0.228
R7438 XRX.XFRONT.XFE_E.XP.n59 XRX.XFRONT.XFE_E.XP.t21 0.228
R7439 XRX.XFRONT.XFE_E.XP.n59 XRX.XFRONT.XFE_E.XP.t22 0.228
R7440 XRX.XFRONT.XFE_E.XP.n57 XRX.XFRONT.XFE_E.XP.t19 0.228
R7441 XRX.XFRONT.XFE_E.XP.n57 XRX.XFRONT.XFE_E.XP.t20 0.228
R7442 XRX.XFRONT.XFE_E.XP.n67 XRX.XFRONT.XFE_E.XP.t8 0.228
R7443 XRX.XFRONT.XFE_E.XP.n67 XRX.XFRONT.XFE_E.XP.t9 0.228
R7444 XRX.XFRONT.XFE_E.XP.n14 XRX.XFRONT.XFE_E.XP.t29 0.20525
R7445 XRX.XFRONT.XFE_E.XP.n14 XRX.XFRONT.XFE_E.XP.t0 0.20525
R7446 XRX.XFRONT.XFE_E.XP.n18 XRX.XFRONT.XFE_E.XP.t4 0.20525
R7447 XRX.XFRONT.XFE_E.XP.n18 XRX.XFRONT.XFE_E.XP.t2 0.20525
R7448 XRX.XFRONT.XFE_E.XP.n16 XRX.XFRONT.XFE_E.XP.t3 0.20525
R7449 XRX.XFRONT.XFE_E.XP.n16 XRX.XFRONT.XFE_E.XP.t30 0.20525
R7450 XRX.XFRONT.XFE_E.XP.n77 XRX.XFRONT.XFE_E.XP.t28 0.20525
R7451 XRX.XFRONT.XFE_E.XP.n77 XRX.XFRONT.XFE_E.XP.t27 0.20525
R7452 XRX.XFRONT.XFE_E.XP.n68 XRX.XFRONT.XFE_E.XP.n66 0.189974
R7453 XRX.XFRONT.XFE_E.XP.n66 XRX.XFRONT.XFE_E.XP.n64 0.189974
R7454 XRX.XFRONT.XFE_E.XP.n19 XRX.XFRONT.XFE_E.XP.n17 0.189974
R7455 XRX.XFRONT.XFE_E.XP.n73 XRX.XFRONT.XFE_E.XP.n71 0.189974
R7456 XRX.XFRONT.XFE_E.XP.n75 XRX.XFRONT.XFE_E.XP.n73 0.189974
R7457 XRX.XFRONT.XFE_E.XP.n76 XRX.XFRONT.XFE_E.XP.n75 0.189974
R7458 XRX.XFRONT.XFE_E.XP.n60 XRX.XFRONT.XFE_E.XP.n58 0.189974
R7459 XRX.XFRONT.XFE_E.XP.n61 XRX.XFRONT.XFE_E.XP.n60 0.189974
R7460 XRX.XFRONT.XFE_E.XP.n26 XRX.XFRONT.XFE_E.XP.n21 0.1205
R7461 XRX.XFRONT.XFE_E.XP.n4 XRX.XFRONT.XFE_E.XP.n3 0.1205
R7462 XRX.XFRONT.XFE_E.XP.n3 XRX.XFRONT.XFE_E.XP.n2 0.1205
R7463 XRX.XFRONT.XFE_E.XP.n2 XRX.XFRONT.XFE_E.XP.n1 0.1205
R7464 XRX.XFRONT.XFE_E.XP.n1 XRX.XFRONT.XFE_E.XP.n0 0.1205
R7465 XRX.XFRONT.XFE_E.XP.n13 XRX.XFRONT.XFE_E.XP.n0 0.1205
R7466 XRX.XFRONT.XFE_E.XP.n49 XRX.XFRONT.XFE_E.XP.n30 0.1205
R7467 XRX.XFRONT.XFE_E.XP.n31 XRX.XFRONT.XFE_E.XP.n30 0.1205
R7468 XRX.XFRONT.XFE_E.XP.n32 XRX.XFRONT.XFE_E.XP.n31 0.1205
R7469 XRX.XFRONT.XFE_E.XP.n33 XRX.XFRONT.XFE_E.XP.n32 0.1205
R7470 XRX.XFRONT.XFE_E.XP.n34 XRX.XFRONT.XFE_E.XP.n33 0.1205
R7471 XRX.XFRONT.XFE_E.XP.n35 XRX.XFRONT.XFE_E.XP.n29 0.1205
R7472 XRX.XFRONT.XFE_E.XP.n36 XRX.XFRONT.XFE_E.XP.n35 0.1205
R7473 XRX.XFRONT.XFE_E.XP.n37 XRX.XFRONT.XFE_E.XP.n36 0.1205
R7474 XRX.XFRONT.XFE_E.XP.n38 XRX.XFRONT.XFE_E.XP.n37 0.1205
R7475 XRX.XFRONT.XFE_E.XP.n39 XRX.XFRONT.XFE_E.XP.n38 0.1205
R7476 XRX.XFRONT.XFE_E.XP.n40 XRX.XFRONT.XFE_E.XP.n39 0.1205
R7477 XRX.XFRONT.XFE_E.XP.n20 XRX.XFRONT.XFE_E.XP.n19 0.0952368
R7478 XRX.XFRONT.XFE_E.XP.n20 XRX.XFRONT.XFE_E.XP.n15 0.0952368
R7479 XRX.XFRONT.XFE_E.XN.t57 XRX.XFRONT.XFE_E.XN.n12 127.788
R7480 XRX.XFRONT.XFE_E.XN.n5 XRX.XFRONT.XFE_E.XN.t50 127.788
R7481 XRX.XFRONT.XFE_E.XN.t52 XRX.XFRONT.XFE_E.XN.n6 127.668
R7482 XRX.XFRONT.XFE_E.XN.n12 XRX.XFRONT.XFE_E.XN.t56 127.668
R7483 XRX.XFRONT.XFE_E.XN.n11 XRX.XFRONT.XFE_E.XN.t55 127.668
R7484 XRX.XFRONT.XFE_E.XN.n10 XRX.XFRONT.XFE_E.XN.t54 127.668
R7485 XRX.XFRONT.XFE_E.XN.n9 XRX.XFRONT.XFE_E.XN.t53 127.668
R7486 XRX.XFRONT.XFE_E.XN.n5 XRX.XFRONT.XFE_E.XN.t51 127.668
R7487 XRX.XFRONT.XFE_E.XN.n21 XRX.XFRONT.XFE_E.XN.t35 113.632
R7488 XRX.XFRONT.XFE_E.XN.n13 XRX.XFRONT.XFE_E.XN.t57 113.632
R7489 XRX.XFRONT.XFE_E.XN.t50 XRX.XFRONT.XFE_E.XN.n4 113.632
R7490 XRX.XFRONT.XFE_E.XN.n48 XRX.XFRONT.XFE_E.XN.t38 113.632
R7491 XRX.XFRONT.XFE_E.XN.n29 XRX.XFRONT.XFE_E.XN.t42 113.632
R7492 XRX.XFRONT.XFE_E.XN.n23 XRX.XFRONT.XFE_E.XN.t37 109.174
R7493 XRX.XFRONT.XFE_E.XN.n22 XRX.XFRONT.XFE_E.XN.t36 109.174
R7494 XRX.XFRONT.XFE_E.XN.n7 XRX.XFRONT.XFE_E.XN.t52 109.174
R7495 XRX.XFRONT.XFE_E.XN.t56 XRX.XFRONT.XFE_E.XN.n8 109.174
R7496 XRX.XFRONT.XFE_E.XN.n15 XRX.XFRONT.XFE_E.XN.t55 109.174
R7497 XRX.XFRONT.XFE_E.XN.n16 XRX.XFRONT.XFE_E.XN.t54 109.174
R7498 XRX.XFRONT.XFE_E.XN.n17 XRX.XFRONT.XFE_E.XN.t53 109.174
R7499 XRX.XFRONT.XFE_E.XN.t51 XRX.XFRONT.XFE_E.XN.n3 109.174
R7500 XRX.XFRONT.XFE_E.XN.n51 XRX.XFRONT.XFE_E.XN.t41 109.174
R7501 XRX.XFRONT.XFE_E.XN.n50 XRX.XFRONT.XFE_E.XN.t40 109.174
R7502 XRX.XFRONT.XFE_E.XN.n49 XRX.XFRONT.XFE_E.XN.t39 109.174
R7503 XRX.XFRONT.XFE_E.XN.n36 XRX.XFRONT.XFE_E.XN.t47 109.174
R7504 XRX.XFRONT.XFE_E.XN.n37 XRX.XFRONT.XFE_E.XN.t48 109.174
R7505 XRX.XFRONT.XFE_E.XN.n38 XRX.XFRONT.XFE_E.XN.t49 109.174
R7506 XRX.XFRONT.XFE_E.XN.n27 XRX.XFRONT.XFE_E.XN.t46 109.174
R7507 XRX.XFRONT.XFE_E.XN.n32 XRX.XFRONT.XFE_E.XN.t45 109.174
R7508 XRX.XFRONT.XFE_E.XN.n31 XRX.XFRONT.XFE_E.XN.t44 109.174
R7509 XRX.XFRONT.XFE_E.XN.n30 XRX.XFRONT.XFE_E.XN.t43 109.174
R7510 XRX.XFRONT.XFE_E.XN.n72 XRX.XFRONT.XFE_E.XN.n71 21.0284
R7511 XRX.XFRONT.XFE_E.XN.n80 XRX.XFRONT.XFE_E.XN.n79 18.9712
R7512 XRX.XFRONT.XFE_E.XN.n39 XRX.XFRONT.XFE_E.XN.n38 18.5723
R7513 XRX.XFRONT.XFE_E.XN.n24 XRX.XFRONT.XFE_E.XN.n23 18.4942
R7514 XRX.XFRONT.XFE_E.XN.n7 XRX.XFRONT.XFE_E.XN.n1 18.4942
R7515 XRX.XFRONT.XFE_E.XN.n15 XRX.XFRONT.XFE_E.XN.n14 18.4942
R7516 XRX.XFRONT.XFE_E.XN.n16 XRX.XFRONT.XFE_E.XN.n2 18.4942
R7517 XRX.XFRONT.XFE_E.XN.n18 XRX.XFRONT.XFE_E.XN.n17 18.4942
R7518 XRX.XFRONT.XFE_E.XN.n52 XRX.XFRONT.XFE_E.XN.n51 18.4942
R7519 XRX.XFRONT.XFE_E.XN.n50 XRX.XFRONT.XFE_E.XN.n47 18.4942
R7520 XRX.XFRONT.XFE_E.XN.n36 XRX.XFRONT.XFE_E.XN.n35 18.4942
R7521 XRX.XFRONT.XFE_E.XN.n37 XRX.XFRONT.XFE_E.XN.n26 18.4942
R7522 XRX.XFRONT.XFE_E.XN.n34 XRX.XFRONT.XFE_E.XN.n27 18.4942
R7523 XRX.XFRONT.XFE_E.XN.n33 XRX.XFRONT.XFE_E.XN.n32 18.4942
R7524 XRX.XFRONT.XFE_E.XN.n31 XRX.XFRONT.XFE_E.XN.n28 18.4942
R7525 XRX.XFRONT.XFE_E.XN.n25 XRX.XFRONT.XFE_E.XN.n24 16.6599
R7526 XRX.XFRONT.XFE_E.XN.n64 XRX.XFRONT.XFE_E.XN.n61 12.6712
R7527 XRX.XFRONT.XFE_E.XN.n23 XRX.XFRONT.XFE_E.XN.n22 11.6805
R7528 XRX.XFRONT.XFE_E.XN.n16 XRX.XFRONT.XFE_E.XN.n15 11.6805
R7529 XRX.XFRONT.XFE_E.XN.n15 XRX.XFRONT.XFE_E.XN.n8 11.6805
R7530 XRX.XFRONT.XFE_E.XN.n17 XRX.XFRONT.XFE_E.XN.n16 11.6805
R7531 XRX.XFRONT.XFE_E.XN.n17 XRX.XFRONT.XFE_E.XN.n7 11.6805
R7532 XRX.XFRONT.XFE_E.XN.n7 XRX.XFRONT.XFE_E.XN.n3 11.6805
R7533 XRX.XFRONT.XFE_E.XN.n51 XRX.XFRONT.XFE_E.XN.n50 11.6805
R7534 XRX.XFRONT.XFE_E.XN.n50 XRX.XFRONT.XFE_E.XN.n49 11.6805
R7535 XRX.XFRONT.XFE_E.XN.n36 XRX.XFRONT.XFE_E.XN.n27 11.6805
R7536 XRX.XFRONT.XFE_E.XN.n37 XRX.XFRONT.XFE_E.XN.n36 11.6805
R7537 XRX.XFRONT.XFE_E.XN.n38 XRX.XFRONT.XFE_E.XN.n37 11.6805
R7538 XRX.XFRONT.XFE_E.XN.n32 XRX.XFRONT.XFE_E.XN.n27 11.6805
R7539 XRX.XFRONT.XFE_E.XN.n32 XRX.XFRONT.XFE_E.XN.n31 11.6805
R7540 XRX.XFRONT.XFE_E.XN.n31 XRX.XFRONT.XFE_E.XN.n30 11.6805
R7541 XRX.XFRONT.XFE_E.XN.n20 XRX.XFRONT.XFE_E.XN.n0 10.8396
R7542 XRX.XFRONT.XFE_E.XN.n54 XRX.XFRONT.XFE_E.XN.n39 10.7748
R7543 XRX.XFRONT.XFE_E.XN.n64 XRX.XFRONT.XFE_E.XN.n63 9.44001
R7544 XRX.XFRONT.XFE_E.XN.n53 XRX.XFRONT.XFE_E.XN.n52 9.1385
R7545 XRX.XFRONT.XFE_E.XN.n20 XRX.XFRONT.XFE_E.XN.n19 9.0005
R7546 XRX.XFRONT.XFE_E.XN.n24 XRX.XFRONT.XFE_E.XN.n21 7.17687
R7547 XRX.XFRONT.XFE_E.XN.n14 XRX.XFRONT.XFE_E.XN.n13 7.17687
R7548 XRX.XFRONT.XFE_E.XN.n4 XRX.XFRONT.XFE_E.XN.n1 7.17687
R7549 XRX.XFRONT.XFE_E.XN.n48 XRX.XFRONT.XFE_E.XN.n47 7.17687
R7550 XRX.XFRONT.XFE_E.XN.n29 XRX.XFRONT.XFE_E.XN.n28 7.17687
R7551 XRX.XFRONT.XFE_E.XN.n65 XRX.XFRONT.XFE_E.XN.n54 6.41789
R7552 XRX.XFRONT.XFE_E.XN.n53 XRX.XFRONT.XFE_E.XN.n46 6.40336
R7553 XRX.XFRONT.XFE_E.XN.n41 XRX.XFRONT.XFE_E.XN.t16 5.7796
R7554 XRX.XFRONT.XFE_E.XN.n43 XRX.XFRONT.XFE_E.XN.t1 5.7796
R7555 XRX.XFRONT.XFE_E.XN.n71 XRX.XFRONT.XFE_E.XN.t24 5.73764
R7556 XRX.XFRONT.XFE_E.XN.n56 XRX.XFRONT.XFE_E.XN.t15 5.73764
R7557 XRX.XFRONT.XFE_E.XN.n60 XRX.XFRONT.XFE_E.XN.t8 5.73764
R7558 XRX.XFRONT.XFE_E.XN.n67 XRX.XFRONT.XFE_E.XN.t17 5.73764
R7559 XRX.XFRONT.XFE_E.XN.n25 XRX.XFRONT.XFE_E.XN.n20 5.63193
R7560 XRX.XFRONT.XFE_E.XN.n63 XRX.XFRONT.XFE_E.XN.t14 5.59012
R7561 XRX.XFRONT.XFE_E.XN.n63 XRX.XFRONT.XFE_E.XN.n62 5.57485
R7562 XRX.XFRONT.XFE_E.XN.n75 XRX.XFRONT.XFE_E.XN.n73 5.51014
R7563 XRX.XFRONT.XFE_E.XN.n79 XRX.XFRONT.XFE_E.XN.n78 5.4154
R7564 XRX.XFRONT.XFE_E.XN.n41 XRX.XFRONT.XFE_E.XN.n40 5.38537
R7565 XRX.XFRONT.XFE_E.XN.n45 XRX.XFRONT.XFE_E.XN.n44 5.38537
R7566 XRX.XFRONT.XFE_E.XN.n43 XRX.XFRONT.XFE_E.XN.n42 5.38537
R7567 XRX.XFRONT.XFE_E.XN.n75 XRX.XFRONT.XFE_E.XN.n74 5.32067
R7568 XRX.XFRONT.XFE_E.XN.n77 XRX.XFRONT.XFE_E.XN.n76 5.32067
R7569 XRX.XFRONT.XFE_E.XN.n56 XRX.XFRONT.XFE_E.XN.n55 5.32067
R7570 XRX.XFRONT.XFE_E.XN.n58 XRX.XFRONT.XFE_E.XN.n57 5.32067
R7571 XRX.XFRONT.XFE_E.XN.n60 XRX.XFRONT.XFE_E.XN.n59 5.32067
R7572 XRX.XFRONT.XFE_E.XN.n71 XRX.XFRONT.XFE_E.XN.n70 5.32067
R7573 XRX.XFRONT.XFE_E.XN.n69 XRX.XFRONT.XFE_E.XN.n68 5.32067
R7574 XRX.XFRONT.XFE_E.XN.n67 XRX.XFRONT.XFE_E.XN.n66 5.32067
R7575 XRX.XFRONT.XFE_E.XN XRX.XFRONT.XFE_E.XN.n25 4.53963
R7576 XRX.XFRONT.XFE_E.XN.n65 XRX.XFRONT.XFE_E.XN.n64 4.5005
R7577 XRX.XFRONT.XFE_E.XN.n22 XRX.XFRONT.XFE_E.XN.n21 4.42851
R7578 XRX.XFRONT.XFE_E.XN.n13 XRX.XFRONT.XFE_E.XN.n8 4.42851
R7579 XRX.XFRONT.XFE_E.XN.n4 XRX.XFRONT.XFE_E.XN.n3 4.42851
R7580 XRX.XFRONT.XFE_E.XN.n49 XRX.XFRONT.XFE_E.XN.n48 4.42851
R7581 XRX.XFRONT.XFE_E.XN.n30 XRX.XFRONT.XFE_E.XN.n29 4.42851
R7582 XRX.XFRONT.XFE_E.XN XRX.XFRONT.XFE_E.XN.n80 3.91354
R7583 XRX.XFRONT.XFE_E.XN.n54 XRX.XFRONT.XFE_E.XN.n53 2.93193
R7584 XRX.XFRONT.XFE_E.XN.n72 XRX.XFRONT.XFE_E.XN.n65 1.76137
R7585 XRX.XFRONT.XFE_E.XN.n80 XRX.XFRONT.XFE_E.XN.n72 1.72224
R7586 XRX.XFRONT.XFE_E.XN.n73 XRX.XFRONT.XFE_E.XN.t31 0.228
R7587 XRX.XFRONT.XFE_E.XN.n73 XRX.XFRONT.XFE_E.XN.t32 0.228
R7588 XRX.XFRONT.XFE_E.XN.n74 XRX.XFRONT.XFE_E.XN.t29 0.228
R7589 XRX.XFRONT.XFE_E.XN.n74 XRX.XFRONT.XFE_E.XN.t30 0.228
R7590 XRX.XFRONT.XFE_E.XN.n76 XRX.XFRONT.XFE_E.XN.t27 0.228
R7591 XRX.XFRONT.XFE_E.XN.n76 XRX.XFRONT.XFE_E.XN.t28 0.228
R7592 XRX.XFRONT.XFE_E.XN.n78 XRX.XFRONT.XFE_E.XN.t25 0.228
R7593 XRX.XFRONT.XFE_E.XN.n78 XRX.XFRONT.XFE_E.XN.t26 0.228
R7594 XRX.XFRONT.XFE_E.XN.n55 XRX.XFRONT.XFE_E.XN.t5 0.228
R7595 XRX.XFRONT.XFE_E.XN.n55 XRX.XFRONT.XFE_E.XN.t6 0.228
R7596 XRX.XFRONT.XFE_E.XN.n57 XRX.XFRONT.XFE_E.XN.t9 0.228
R7597 XRX.XFRONT.XFE_E.XN.n57 XRX.XFRONT.XFE_E.XN.t10 0.228
R7598 XRX.XFRONT.XFE_E.XN.n59 XRX.XFRONT.XFE_E.XN.t7 0.228
R7599 XRX.XFRONT.XFE_E.XN.n59 XRX.XFRONT.XFE_E.XN.t11 0.228
R7600 XRX.XFRONT.XFE_E.XN.n70 XRX.XFRONT.XFE_E.XN.t22 0.228
R7601 XRX.XFRONT.XFE_E.XN.n70 XRX.XFRONT.XFE_E.XN.t23 0.228
R7602 XRX.XFRONT.XFE_E.XN.n68 XRX.XFRONT.XFE_E.XN.t20 0.228
R7603 XRX.XFRONT.XFE_E.XN.n68 XRX.XFRONT.XFE_E.XN.t21 0.228
R7604 XRX.XFRONT.XFE_E.XN.n66 XRX.XFRONT.XFE_E.XN.t18 0.228
R7605 XRX.XFRONT.XFE_E.XN.n66 XRX.XFRONT.XFE_E.XN.t19 0.228
R7606 XRX.XFRONT.XFE_E.XN.n40 XRX.XFRONT.XFE_E.XN.t4 0.20525
R7607 XRX.XFRONT.XFE_E.XN.n40 XRX.XFRONT.XFE_E.XN.t34 0.20525
R7608 XRX.XFRONT.XFE_E.XN.n44 XRX.XFRONT.XFE_E.XN.t33 0.20525
R7609 XRX.XFRONT.XFE_E.XN.n44 XRX.XFRONT.XFE_E.XN.t0 0.20525
R7610 XRX.XFRONT.XFE_E.XN.n42 XRX.XFRONT.XFE_E.XN.t2 0.20525
R7611 XRX.XFRONT.XFE_E.XN.n42 XRX.XFRONT.XFE_E.XN.t3 0.20525
R7612 XRX.XFRONT.XFE_E.XN.n62 XRX.XFRONT.XFE_E.XN.t12 0.20525
R7613 XRX.XFRONT.XFE_E.XN.n62 XRX.XFRONT.XFE_E.XN.t13 0.20525
R7614 XRX.XFRONT.XFE_E.XN.n69 XRX.XFRONT.XFE_E.XN.n67 0.189974
R7615 XRX.XFRONT.XFE_E.XN.n71 XRX.XFRONT.XFE_E.XN.n69 0.189974
R7616 XRX.XFRONT.XFE_E.XN.n77 XRX.XFRONT.XFE_E.XN.n75 0.189974
R7617 XRX.XFRONT.XFE_E.XN.n45 XRX.XFRONT.XFE_E.XN.n43 0.189974
R7618 XRX.XFRONT.XFE_E.XN.n58 XRX.XFRONT.XFE_E.XN.n56 0.189974
R7619 XRX.XFRONT.XFE_E.XN.n61 XRX.XFRONT.XFE_E.XN.n58 0.166289
R7620 XRX.XFRONT.XFE_E.XN.n6 XRX.XFRONT.XFE_E.XN.n5 0.1205
R7621 XRX.XFRONT.XFE_E.XN.n12 XRX.XFRONT.XFE_E.XN.n11 0.1205
R7622 XRX.XFRONT.XFE_E.XN.n11 XRX.XFRONT.XFE_E.XN.n10 0.1205
R7623 XRX.XFRONT.XFE_E.XN.n14 XRX.XFRONT.XFE_E.XN.n2 0.1205
R7624 XRX.XFRONT.XFE_E.XN.n52 XRX.XFRONT.XFE_E.XN.n47 0.1205
R7625 XRX.XFRONT.XFE_E.XN.n35 XRX.XFRONT.XFE_E.XN.n34 0.1205
R7626 XRX.XFRONT.XFE_E.XN.n34 XRX.XFRONT.XFE_E.XN.n33 0.1205
R7627 XRX.XFRONT.XFE_E.XN.n33 XRX.XFRONT.XFE_E.XN.n28 0.1205
R7628 XRX.XFRONT.XFE_E.XN.n10 XRX.XFRONT.XFE_E.XN.n9 0.114816
R7629 XRX.XFRONT.XFE_E.XN.n18 XRX.XFRONT.XFE_E.XN.n2 0.114816
R7630 XRX.XFRONT.XFE_E.XN.n35 XRX.XFRONT.XFE_E.XN.n26 0.114816
R7631 XRX.XFRONT.XFE_E.XN.n79 XRX.XFRONT.XFE_E.XN.n77 0.0952368
R7632 XRX.XFRONT.XFE_E.XN.n46 XRX.XFRONT.XFE_E.XN.n45 0.0952368
R7633 XRX.XFRONT.XFE_E.XN.n46 XRX.XFRONT.XFE_E.XN.n41 0.0952368
R7634 XRX.XFRONT.XFE_E.XN.n19 XRX.XFRONT.XFE_E.XN.n1 0.0785
R7635 XRX.XFRONT.XFE_E.XN.n6 XRX.XFRONT.XFE_E.XN.n0 0.0785
R7636 XRX.XFRONT.XFE_E.XN.n19 XRX.XFRONT.XFE_E.XN.n18 0.0241842
R7637 XRX.XFRONT.XFE_E.XN.n9 XRX.XFRONT.XFE_E.XN.n0 0.0241842
R7638 XRX.XFRONT.XFE_E.XN.n39 XRX.XFRONT.XFE_E.XN.n26 0.0241842
R7639 XRX.XFRONT.XFE_E.XN.n61 XRX.XFRONT.XFE_E.XN.n60 0.0241842
R7640 XRX.XFRONT.XFE_O.VREGN.n14 XRX.XFRONT.XFE_O.VREGN.n6 11.1284
R7641 XRX.XFRONT.XFE_O.VREGN.n14 XRX.XFRONT.XFE_O.VREGN.n13 8.37084
R7642 XRX.XFRONT.XFE_O.VREGN.n1 XRX.XFRONT.XFE_O.VREGN.t7 5.73764
R7643 XRX.XFRONT.XFE_O.VREGN.n3 XRX.XFRONT.XFE_O.VREGN.t0 5.73764
R7644 XRX.XFRONT.XFE_O.VREGN.n9 XRX.XFRONT.XFE_O.VREGN.n7 5.51014
R7645 XRX.XFRONT.XFE_O.VREGN.n13 XRX.XFRONT.XFE_O.VREGN.n12 5.32067
R7646 XRX.XFRONT.XFE_O.VREGN.n11 XRX.XFRONT.XFE_O.VREGN.n10 5.32067
R7647 XRX.XFRONT.XFE_O.VREGN.n9 XRX.XFRONT.XFE_O.VREGN.n8 5.32067
R7648 XRX.XFRONT.XFE_O.VREGN.n1 XRX.XFRONT.XFE_O.VREGN.n0 5.32067
R7649 XRX.XFRONT.XFE_O.VREGN.n5 XRX.XFRONT.XFE_O.VREGN.n4 5.32067
R7650 XRX.XFRONT.XFE_O.VREGN.n3 XRX.XFRONT.XFE_O.VREGN.n2 5.32067
R7651 XRX.XFRONT.XFE_O.VREGN XRX.XFRONT.XFE_O.VREGN.n14 4.53963
R7652 XRX.XFRONT.XFE_O.VREGN.n12 XRX.XFRONT.XFE_O.VREGN.t14 0.228
R7653 XRX.XFRONT.XFE_O.VREGN.n12 XRX.XFRONT.XFE_O.VREGN.t15 0.228
R7654 XRX.XFRONT.XFE_O.VREGN.n10 XRX.XFRONT.XFE_O.VREGN.t12 0.228
R7655 XRX.XFRONT.XFE_O.VREGN.n10 XRX.XFRONT.XFE_O.VREGN.t13 0.228
R7656 XRX.XFRONT.XFE_O.VREGN.n8 XRX.XFRONT.XFE_O.VREGN.t10 0.228
R7657 XRX.XFRONT.XFE_O.VREGN.n8 XRX.XFRONT.XFE_O.VREGN.t11 0.228
R7658 XRX.XFRONT.XFE_O.VREGN.n7 XRX.XFRONT.XFE_O.VREGN.t8 0.228
R7659 XRX.XFRONT.XFE_O.VREGN.n7 XRX.XFRONT.XFE_O.VREGN.t9 0.228
R7660 XRX.XFRONT.XFE_O.VREGN.n0 XRX.XFRONT.XFE_O.VREGN.t5 0.228
R7661 XRX.XFRONT.XFE_O.VREGN.n0 XRX.XFRONT.XFE_O.VREGN.t6 0.228
R7662 XRX.XFRONT.XFE_O.VREGN.n4 XRX.XFRONT.XFE_O.VREGN.t3 0.228
R7663 XRX.XFRONT.XFE_O.VREGN.n4 XRX.XFRONT.XFE_O.VREGN.t4 0.228
R7664 XRX.XFRONT.XFE_O.VREGN.n2 XRX.XFRONT.XFE_O.VREGN.t1 0.228
R7665 XRX.XFRONT.XFE_O.VREGN.n2 XRX.XFRONT.XFE_O.VREGN.t2 0.228
R7666 XRX.XFRONT.XFE_O.VREGN.n5 XRX.XFRONT.XFE_O.VREGN.n3 0.189974
R7667 XRX.XFRONT.XFE_O.VREGN.n11 XRX.XFRONT.XFE_O.VREGN.n9 0.189974
R7668 XRX.XFRONT.XFE_O.VREGN.n13 XRX.XFRONT.XFE_O.VREGN.n11 0.189974
R7669 XRX.XFRONT.XFE_O.VREGN.n6 XRX.XFRONT.XFE_O.VREGN.n5 0.0952368
R7670 XRX.XFRONT.XFE_O.VREGN.n6 XRX.XFRONT.XFE_O.VREGN.n1 0.0952368
R7671 XRX.XFRONT.XFE_O.SB.n20 XRX.XFRONT.XFE_O.SB.t14 127.788
R7672 XRX.XFRONT.XFE_O.SB.n13 XRX.XFRONT.XFE_O.SB.t7 127.788
R7673 XRX.XFRONT.XFE_O.SB.t10 XRX.XFRONT.XFE_O.SB.n15 127.668
R7674 XRX.XFRONT.XFE_O.SB.n20 XRX.XFRONT.XFE_O.SB.t13 127.668
R7675 XRX.XFRONT.XFE_O.SB.t12 XRX.XFRONT.XFE_O.SB.n21 127.668
R7676 XRX.XFRONT.XFE_O.SB.n18 XRX.XFRONT.XFE_O.SB.t11 127.668
R7677 XRX.XFRONT.XFE_O.SB.n13 XRX.XFRONT.XFE_O.SB.t8 127.668
R7678 XRX.XFRONT.XFE_O.SB.n14 XRX.XFRONT.XFE_O.SB.t9 127.668
R7679 XRX.XFRONT.XFE_O.SB.t14 XRX.XFRONT.XFE_O.SB.n19 113.632
R7680 XRX.XFRONT.XFE_O.SB.n11 XRX.XFRONT.XFE_O.SB.t7 113.632
R7681 XRX.XFRONT.XFE_O.SB.n16 XRX.XFRONT.XFE_O.SB.t10 109.174
R7682 XRX.XFRONT.XFE_O.SB.t13 XRX.XFRONT.XFE_O.SB.n17 109.174
R7683 XRX.XFRONT.XFE_O.SB.n22 XRX.XFRONT.XFE_O.SB.t12 109.174
R7684 XRX.XFRONT.XFE_O.SB.n23 XRX.XFRONT.XFE_O.SB.t11 109.174
R7685 XRX.XFRONT.XFE_O.SB.t8 XRX.XFRONT.XFE_O.SB.n12 109.174
R7686 XRX.XFRONT.XFE_O.SB.t9 XRX.XFRONT.XFE_O.SB.n9 109.174
R7687 XRX.XFRONT.XFE_O.SB.n4 XRX.XFRONT.XFE_O.SB.t0 24.3193
R7688 XRX.XFRONT.XFE_O.SB.n16 XRX.XFRONT.XFE_O.SB.n7 18.4942
R7689 XRX.XFRONT.XFE_O.SB.n22 XRX.XFRONT.XFE_O.SB.n8 18.4942
R7690 XRX.XFRONT.XFE_O.SB.n24 XRX.XFRONT.XFE_O.SB.n23 18.4942
R7691 XRX.XFRONT.XFE_O.SB.n10 XRX.XFRONT.XFE_O.SB.n9 18.4942
R7692 XRX.XFRONT.XFE_O.SB.n5 XRX.XFRONT.XFE_O.SB.n4 16.5284
R7693 XRX.XFRONT.XFE_O.SB.n2 XRX.XFRONT.XFE_O.SB.n0 13.9299
R7694 XRX.XFRONT.XFE_O.SB.n23 XRX.XFRONT.XFE_O.SB.n22 11.6805
R7695 XRX.XFRONT.XFE_O.SB.n22 XRX.XFRONT.XFE_O.SB.n17 11.6805
R7696 XRX.XFRONT.XFE_O.SB.n23 XRX.XFRONT.XFE_O.SB.n16 11.6805
R7697 XRX.XFRONT.XFE_O.SB.n12 XRX.XFRONT.XFE_O.SB.n9 11.6805
R7698 XRX.XFRONT.XFE_O.SB.n16 XRX.XFRONT.XFE_O.SB.n9 11.6805
R7699 XRX.XFRONT.XFE_O.SB.n5 XRX.XFRONT.XFE_O.SB.n2 11.5728
R7700 XRX.XFRONT.XFE_O.SB.n26 XRX.XFRONT.XFE_O.SB.n6 10.8396
R7701 XRX.XFRONT.XFE_O.SB.n4 XRX.XFRONT.XFE_O.SB.n3 10.1049
R7702 XRX.XFRONT.XFE_O.SB.n26 XRX.XFRONT.XFE_O.SB.n25 9.0005
R7703 XRX.XFRONT.XFE_O.SB.n19 XRX.XFRONT.XFE_O.SB.n8 7.17687
R7704 XRX.XFRONT.XFE_O.SB.n11 XRX.XFRONT.XFE_O.SB.n10 7.17687
R7705 XRX.XFRONT.XFE_O.SB.n27 XRX.XFRONT.XFE_O.SB.n26 6.72479
R7706 XRX.XFRONT.XFE_O.SB.n27 XRX.XFRONT.XFE_O.SB.n5 6.33963
R7707 XRX.XFRONT.XFE_O.SB.n1 XRX.XFRONT.XFE_O.SB.t6 5.7796
R7708 XRX.XFRONT.XFE_O.SB.n0 XRX.XFRONT.XFE_O.SB.t1 5.73764
R7709 XRX.XFRONT.XFE_O.SB.n1 XRX.XFRONT.XFE_O.SB.t5 5.59012
R7710 XRX.XFRONT.XFE_O.SB.n0 XRX.XFRONT.XFE_O.SB.t2 5.54817
R7711 XRX.XFRONT.XFE_O.SB.n2 XRX.XFRONT.XFE_O.SB.n1 4.5005
R7712 XRX.XFRONT.XFE_O.SB.n19 XRX.XFRONT.XFE_O.SB.n17 4.42851
R7713 XRX.XFRONT.XFE_O.SB.n12 XRX.XFRONT.XFE_O.SB.n11 4.42851
R7714 XRX.XFRONT.XFE_O.SB.n3 XRX.XFRONT.XFE_O.SB.t4 0.228
R7715 XRX.XFRONT.XFE_O.SB.n3 XRX.XFRONT.XFE_O.SB.t3 0.228
R7716 XRX.XFRONT.XFE_O.SB.n10 XRX.XFRONT.XFE_O.SB.n7 0.1205
R7717 XRX.XFRONT.XFE_O.SB.n15 XRX.XFRONT.XFE_O.SB.n14 0.1205
R7718 XRX.XFRONT.XFE_O.SB.n14 XRX.XFRONT.XFE_O.SB.n13 0.1205
R7719 XRX.XFRONT.XFE_O.SB.n21 XRX.XFRONT.XFE_O.SB.n20 0.1205
R7720 XRX.XFRONT.XFE_O.SB.n21 XRX.XFRONT.XFE_O.SB.n18 0.1205
R7721 XRX.XFRONT.XFE_O.SB.n24 XRX.XFRONT.XFE_O.SB.n8 0.1205
R7722 XRX.XFRONT.XFE_O.SB.n25 XRX.XFRONT.XFE_O.SB.n7 0.0485
R7723 XRX.XFRONT.XFE_O.SB.n15 XRX.XFRONT.XFE_O.SB.n6 0.0485
R7724 XRX.XFRONT.XFE_O.SB.n18 XRX.XFRONT.XFE_O.SB.n6 0.0485
R7725 XRX.XFRONT.XFE_O.SB.n25 XRX.XFRONT.XFE_O.SB.n24 0.0485
R7726 XRX.XFRONT.XFE_O.SB XRX.XFRONT.XFE_O.SB.n27 0.0396304
R7727 XRX.XFRONT.XFE_O.SA.n14 XRX.XFRONT.XFE_O.SA.t14 127.788
R7728 XRX.XFRONT.XFE_O.SA.n7 XRX.XFRONT.XFE_O.SA.t7 127.788
R7729 XRX.XFRONT.XFE_O.SA.t10 XRX.XFRONT.XFE_O.SA.n9 127.668
R7730 XRX.XFRONT.XFE_O.SA.n14 XRX.XFRONT.XFE_O.SA.t13 127.668
R7731 XRX.XFRONT.XFE_O.SA.t12 XRX.XFRONT.XFE_O.SA.n15 127.668
R7732 XRX.XFRONT.XFE_O.SA.n12 XRX.XFRONT.XFE_O.SA.t11 127.668
R7733 XRX.XFRONT.XFE_O.SA.n7 XRX.XFRONT.XFE_O.SA.t8 127.668
R7734 XRX.XFRONT.XFE_O.SA.n8 XRX.XFRONT.XFE_O.SA.t9 127.668
R7735 XRX.XFRONT.XFE_O.SA.t14 XRX.XFRONT.XFE_O.SA.n13 113.632
R7736 XRX.XFRONT.XFE_O.SA.n5 XRX.XFRONT.XFE_O.SA.t7 113.632
R7737 XRX.XFRONT.XFE_O.SA.n10 XRX.XFRONT.XFE_O.SA.t10 109.174
R7738 XRX.XFRONT.XFE_O.SA.t13 XRX.XFRONT.XFE_O.SA.n11 109.174
R7739 XRX.XFRONT.XFE_O.SA.n16 XRX.XFRONT.XFE_O.SA.t12 109.174
R7740 XRX.XFRONT.XFE_O.SA.n17 XRX.XFRONT.XFE_O.SA.t11 109.174
R7741 XRX.XFRONT.XFE_O.SA.t8 XRX.XFRONT.XFE_O.SA.n6 109.174
R7742 XRX.XFRONT.XFE_O.SA.t9 XRX.XFRONT.XFE_O.SA.n3 109.174
R7743 XRX.XFRONT.XFE_O.SA.n22 XRX.XFRONT.XFE_O.SA.t0 22.3095
R7744 XRX.XFRONT.XFE_O.SA.n23 XRX.XFRONT.XFE_O.SA.n22 19.0355
R7745 XRX.XFRONT.XFE_O.SA.n10 XRX.XFRONT.XFE_O.SA.n1 18.4942
R7746 XRX.XFRONT.XFE_O.SA.n16 XRX.XFRONT.XFE_O.SA.n2 18.4942
R7747 XRX.XFRONT.XFE_O.SA.n18 XRX.XFRONT.XFE_O.SA.n17 18.4942
R7748 XRX.XFRONT.XFE_O.SA.n4 XRX.XFRONT.XFE_O.SA.n3 18.4942
R7749 XRX.XFRONT.XFE_O.SA.n26 XRX.XFRONT.XFE_O.SA.n24 14.1193
R7750 XRX.XFRONT.XFE_O.SA.n23 XRX.XFRONT.XFE_O.SA.n20 13.5922
R7751 XRX.XFRONT.XFE_O.SA.n17 XRX.XFRONT.XFE_O.SA.n16 11.6805
R7752 XRX.XFRONT.XFE_O.SA.n16 XRX.XFRONT.XFE_O.SA.n11 11.6805
R7753 XRX.XFRONT.XFE_O.SA.n17 XRX.XFRONT.XFE_O.SA.n10 11.6805
R7754 XRX.XFRONT.XFE_O.SA.n6 XRX.XFRONT.XFE_O.SA.n3 11.6805
R7755 XRX.XFRONT.XFE_O.SA.n10 XRX.XFRONT.XFE_O.SA.n3 11.6805
R7756 XRX.XFRONT.XFE_O.SA.n20 XRX.XFRONT.XFE_O.SA.n0 10.8396
R7757 XRX.XFRONT.XFE_O.SA.n27 XRX.XFRONT.XFE_O.SA.n26 9.71407
R7758 XRX.XFRONT.XFE_O.SA.n20 XRX.XFRONT.XFE_O.SA.n19 9.0005
R7759 XRX.XFRONT.XFE_O.SA.n13 XRX.XFRONT.XFE_O.SA.n2 7.17687
R7760 XRX.XFRONT.XFE_O.SA.n5 XRX.XFRONT.XFE_O.SA.n4 7.17687
R7761 XRX.XFRONT.XFE_O.SA.n25 XRX.XFRONT.XFE_O.SA.t6 5.7796
R7762 XRX.XFRONT.XFE_O.SA.n24 XRX.XFRONT.XFE_O.SA.t2 5.73764
R7763 XRX.XFRONT.XFE_O.SA.n21 XRX.XFRONT.XFE_O.SA.t4 5.73764
R7764 XRX.XFRONT.XFE_O.SA.n25 XRX.XFRONT.XFE_O.SA.t5 5.59012
R7765 XRX.XFRONT.XFE_O.SA.n21 XRX.XFRONT.XFE_O.SA.t3 5.54817
R7766 XRX.XFRONT.XFE_O.SA.n24 XRX.XFRONT.XFE_O.SA.t1 5.54817
R7767 XRX.XFRONT.XFE_O.SA.n22 XRX.XFRONT.XFE_O.SA.n21 4.73734
R7768 XRX.XFRONT.XFE_O.SA.n26 XRX.XFRONT.XFE_O.SA.n25 4.5005
R7769 XRX.XFRONT.XFE_O.SA.n13 XRX.XFRONT.XFE_O.SA.n11 4.42851
R7770 XRX.XFRONT.XFE_O.SA.n6 XRX.XFRONT.XFE_O.SA.n5 4.42851
R7771 XRX.XFRONT.XFE_O.SA.n27 XRX.XFRONT.XFE_O.SA.n23 2.54398
R7772 XRX.XFRONT.XFE_O.SA.n4 XRX.XFRONT.XFE_O.SA.n1 0.1205
R7773 XRX.XFRONT.XFE_O.SA.n9 XRX.XFRONT.XFE_O.SA.n8 0.1205
R7774 XRX.XFRONT.XFE_O.SA.n8 XRX.XFRONT.XFE_O.SA.n7 0.1205
R7775 XRX.XFRONT.XFE_O.SA.n15 XRX.XFRONT.XFE_O.SA.n14 0.1205
R7776 XRX.XFRONT.XFE_O.SA.n15 XRX.XFRONT.XFE_O.SA.n12 0.1205
R7777 XRX.XFRONT.XFE_O.SA.n18 XRX.XFRONT.XFE_O.SA.n2 0.1205
R7778 XRX.XFRONT.XFE_O.SA.n19 XRX.XFRONT.XFE_O.SA.n1 0.0485
R7779 XRX.XFRONT.XFE_O.SA.n9 XRX.XFRONT.XFE_O.SA.n0 0.0485
R7780 XRX.XFRONT.XFE_O.SA.n12 XRX.XFRONT.XFE_O.SA.n0 0.0485
R7781 XRX.XFRONT.XFE_O.SA.n19 XRX.XFRONT.XFE_O.SA.n18 0.0485
R7782 XRX.XFRONT.XFE_O.SA XRX.XFRONT.XFE_O.SA.n27 0.0396304
R7783 XRX.XFRONT.XFE_O.VREGP.n14 XRX.XFRONT.XFE_O.VREGP.n6 16.4697
R7784 XRX.XFRONT.XFE_O.VREGP.n14 XRX.XFRONT.XFE_O.VREGP.n13 12.6577
R7785 XRX.XFRONT.XFE_O.VREGP.n1 XRX.XFRONT.XFE_O.VREGP.t7 5.73764
R7786 XRX.XFRONT.XFE_O.VREGP.n5 XRX.XFRONT.XFE_O.VREGP.t0 5.73764
R7787 XRX.XFRONT.XFE_O.VREGP.n9 XRX.XFRONT.XFE_O.VREGP.n7 5.51014
R7788 XRX.XFRONT.XFE_O.VREGP.n9 XRX.XFRONT.XFE_O.VREGP.n8 5.32067
R7789 XRX.XFRONT.XFE_O.VREGP.n11 XRX.XFRONT.XFE_O.VREGP.n10 5.32067
R7790 XRX.XFRONT.XFE_O.VREGP.n13 XRX.XFRONT.XFE_O.VREGP.n12 5.32067
R7791 XRX.XFRONT.XFE_O.VREGP.n1 XRX.XFRONT.XFE_O.VREGP.n0 5.32067
R7792 XRX.XFRONT.XFE_O.VREGP.n3 XRX.XFRONT.XFE_O.VREGP.n2 5.32067
R7793 XRX.XFRONT.XFE_O.VREGP.n5 XRX.XFRONT.XFE_O.VREGP.n4 5.32067
R7794 XRX.XFRONT.XFE_O.VREGP.n7 XRX.XFRONT.XFE_O.VREGP.t14 0.228
R7795 XRX.XFRONT.XFE_O.VREGP.n7 XRX.XFRONT.XFE_O.VREGP.t15 0.228
R7796 XRX.XFRONT.XFE_O.VREGP.n8 XRX.XFRONT.XFE_O.VREGP.t12 0.228
R7797 XRX.XFRONT.XFE_O.VREGP.n8 XRX.XFRONT.XFE_O.VREGP.t13 0.228
R7798 XRX.XFRONT.XFE_O.VREGP.n10 XRX.XFRONT.XFE_O.VREGP.t10 0.228
R7799 XRX.XFRONT.XFE_O.VREGP.n10 XRX.XFRONT.XFE_O.VREGP.t11 0.228
R7800 XRX.XFRONT.XFE_O.VREGP.n12 XRX.XFRONT.XFE_O.VREGP.t8 0.228
R7801 XRX.XFRONT.XFE_O.VREGP.n12 XRX.XFRONT.XFE_O.VREGP.t9 0.228
R7802 XRX.XFRONT.XFE_O.VREGP.n0 XRX.XFRONT.XFE_O.VREGP.t5 0.228
R7803 XRX.XFRONT.XFE_O.VREGP.n0 XRX.XFRONT.XFE_O.VREGP.t6 0.228
R7804 XRX.XFRONT.XFE_O.VREGP.n2 XRX.XFRONT.XFE_O.VREGP.t3 0.228
R7805 XRX.XFRONT.XFE_O.VREGP.n2 XRX.XFRONT.XFE_O.VREGP.t4 0.228
R7806 XRX.XFRONT.XFE_O.VREGP.n4 XRX.XFRONT.XFE_O.VREGP.t1 0.228
R7807 XRX.XFRONT.XFE_O.VREGP.n4 XRX.XFRONT.XFE_O.VREGP.t2 0.228
R7808 XRX.XFRONT.XFE_O.VREGP.n3 XRX.XFRONT.XFE_O.VREGP.n1 0.189974
R7809 XRX.XFRONT.XFE_O.VREGP.n13 XRX.XFRONT.XFE_O.VREGP.n11 0.189974
R7810 XRX.XFRONT.XFE_O.VREGP.n11 XRX.XFRONT.XFE_O.VREGP.n9 0.189974
R7811 XRX.XFRONT.XFE_O.VREGP.n6 XRX.XFRONT.XFE_O.VREGP.n5 0.0952368
R7812 XRX.XFRONT.XFE_O.VREGP.n6 XRX.XFRONT.XFE_O.VREGP.n3 0.0952368
R7813 XRX.XFRONT.XFE_O.VREGP XRX.XFRONT.XFE_O.VREGP.n14 0.0396304
R7814 XRX.XFRONT.XFE_E.VREGP XRX.XFRONT.XFE_E.VREGP.n13 16.4305
R7815 XRX.XFRONT.XFE_E.VREGP XRX.XFRONT.XFE_E.VREGP.n6 12.6968
R7816 XRX.XFRONT.XFE_E.VREGP.n8 XRX.XFRONT.XFE_E.VREGP.t7 5.73764
R7817 XRX.XFRONT.XFE_E.VREGP.n10 XRX.XFRONT.XFE_E.VREGP.t0 5.73764
R7818 XRX.XFRONT.XFE_E.VREGP.n2 XRX.XFRONT.XFE_E.VREGP.n0 5.51014
R7819 XRX.XFRONT.XFE_E.VREGP.n6 XRX.XFRONT.XFE_E.VREGP.n5 5.32067
R7820 XRX.XFRONT.XFE_E.VREGP.n4 XRX.XFRONT.XFE_E.VREGP.n3 5.32067
R7821 XRX.XFRONT.XFE_E.VREGP.n2 XRX.XFRONT.XFE_E.VREGP.n1 5.32067
R7822 XRX.XFRONT.XFE_E.VREGP.n8 XRX.XFRONT.XFE_E.VREGP.n7 5.32067
R7823 XRX.XFRONT.XFE_E.VREGP.n12 XRX.XFRONT.XFE_E.VREGP.n11 5.32067
R7824 XRX.XFRONT.XFE_E.VREGP.n10 XRX.XFRONT.XFE_E.VREGP.n9 5.32067
R7825 XRX.XFRONT.XFE_E.VREGP.n5 XRX.XFRONT.XFE_E.VREGP.t14 0.228
R7826 XRX.XFRONT.XFE_E.VREGP.n5 XRX.XFRONT.XFE_E.VREGP.t15 0.228
R7827 XRX.XFRONT.XFE_E.VREGP.n3 XRX.XFRONT.XFE_E.VREGP.t12 0.228
R7828 XRX.XFRONT.XFE_E.VREGP.n3 XRX.XFRONT.XFE_E.VREGP.t13 0.228
R7829 XRX.XFRONT.XFE_E.VREGP.n1 XRX.XFRONT.XFE_E.VREGP.t10 0.228
R7830 XRX.XFRONT.XFE_E.VREGP.n1 XRX.XFRONT.XFE_E.VREGP.t11 0.228
R7831 XRX.XFRONT.XFE_E.VREGP.n0 XRX.XFRONT.XFE_E.VREGP.t8 0.228
R7832 XRX.XFRONT.XFE_E.VREGP.n0 XRX.XFRONT.XFE_E.VREGP.t9 0.228
R7833 XRX.XFRONT.XFE_E.VREGP.n7 XRX.XFRONT.XFE_E.VREGP.t5 0.228
R7834 XRX.XFRONT.XFE_E.VREGP.n7 XRX.XFRONT.XFE_E.VREGP.t6 0.228
R7835 XRX.XFRONT.XFE_E.VREGP.n11 XRX.XFRONT.XFE_E.VREGP.t3 0.228
R7836 XRX.XFRONT.XFE_E.VREGP.n11 XRX.XFRONT.XFE_E.VREGP.t4 0.228
R7837 XRX.XFRONT.XFE_E.VREGP.n9 XRX.XFRONT.XFE_E.VREGP.t1 0.228
R7838 XRX.XFRONT.XFE_E.VREGP.n9 XRX.XFRONT.XFE_E.VREGP.t2 0.228
R7839 XRX.XFRONT.XFE_E.VREGP.n12 XRX.XFRONT.XFE_E.VREGP.n10 0.189974
R7840 XRX.XFRONT.XFE_E.VREGP.n4 XRX.XFRONT.XFE_E.VREGP.n2 0.189974
R7841 XRX.XFRONT.XFE_E.VREGP.n6 XRX.XFRONT.XFE_E.VREGP.n4 0.189974
R7842 XRX.XFRONT.XFE_E.VREGP.n13 XRX.XFRONT.XFE_E.VREGP.n12 0.0952368
R7843 XRX.XFRONT.XFE_E.VREGP.n13 XRX.XFRONT.XFE_E.VREGP.n8 0.0952368
R7844 XRX.XFRONT.XFE_E.SA.n17 XRX.XFRONT.XFE_E.SA.t14 127.788
R7845 XRX.XFRONT.XFE_E.SA.n10 XRX.XFRONT.XFE_E.SA.t7 127.788
R7846 XRX.XFRONT.XFE_E.SA.t10 XRX.XFRONT.XFE_E.SA.n12 127.668
R7847 XRX.XFRONT.XFE_E.SA.n17 XRX.XFRONT.XFE_E.SA.t13 127.668
R7848 XRX.XFRONT.XFE_E.SA.t12 XRX.XFRONT.XFE_E.SA.n18 127.668
R7849 XRX.XFRONT.XFE_E.SA.n15 XRX.XFRONT.XFE_E.SA.t11 127.668
R7850 XRX.XFRONT.XFE_E.SA.n10 XRX.XFRONT.XFE_E.SA.t8 127.668
R7851 XRX.XFRONT.XFE_E.SA.n11 XRX.XFRONT.XFE_E.SA.t9 127.668
R7852 XRX.XFRONT.XFE_E.SA.t14 XRX.XFRONT.XFE_E.SA.n16 113.632
R7853 XRX.XFRONT.XFE_E.SA.n8 XRX.XFRONT.XFE_E.SA.t7 113.632
R7854 XRX.XFRONT.XFE_E.SA.n13 XRX.XFRONT.XFE_E.SA.t10 109.174
R7855 XRX.XFRONT.XFE_E.SA.t13 XRX.XFRONT.XFE_E.SA.n14 109.174
R7856 XRX.XFRONT.XFE_E.SA.n19 XRX.XFRONT.XFE_E.SA.t12 109.174
R7857 XRX.XFRONT.XFE_E.SA.n20 XRX.XFRONT.XFE_E.SA.t11 109.174
R7858 XRX.XFRONT.XFE_E.SA.t8 XRX.XFRONT.XFE_E.SA.n9 109.174
R7859 XRX.XFRONT.XFE_E.SA.t9 XRX.XFRONT.XFE_E.SA.n6 109.174
R7860 XRX.XFRONT.XFE_E.SA.n25 XRX.XFRONT.XFE_E.SA.t4 22.3095
R7861 XRX.XFRONT.XFE_E.SA.n26 XRX.XFRONT.XFE_E.SA.n25 19.0355
R7862 XRX.XFRONT.XFE_E.SA.n13 XRX.XFRONT.XFE_E.SA.n4 18.4942
R7863 XRX.XFRONT.XFE_E.SA.n19 XRX.XFRONT.XFE_E.SA.n5 18.4942
R7864 XRX.XFRONT.XFE_E.SA.n21 XRX.XFRONT.XFE_E.SA.n20 18.4942
R7865 XRX.XFRONT.XFE_E.SA.n7 XRX.XFRONT.XFE_E.SA.n6 18.4942
R7866 XRX.XFRONT.XFE_E.SA.n2 XRX.XFRONT.XFE_E.SA.n0 14.1193
R7867 XRX.XFRONT.XFE_E.SA.n26 XRX.XFRONT.XFE_E.SA.n23 13.5922
R7868 XRX.XFRONT.XFE_E.SA.n20 XRX.XFRONT.XFE_E.SA.n19 11.6805
R7869 XRX.XFRONT.XFE_E.SA.n19 XRX.XFRONT.XFE_E.SA.n14 11.6805
R7870 XRX.XFRONT.XFE_E.SA.n20 XRX.XFRONT.XFE_E.SA.n13 11.6805
R7871 XRX.XFRONT.XFE_E.SA.n9 XRX.XFRONT.XFE_E.SA.n6 11.6805
R7872 XRX.XFRONT.XFE_E.SA.n13 XRX.XFRONT.XFE_E.SA.n6 11.6805
R7873 XRX.XFRONT.XFE_E.SA.n23 XRX.XFRONT.XFE_E.SA.n3 10.8396
R7874 XRX.XFRONT.XFE_E.SA XRX.XFRONT.XFE_E.SA.n2 9.7532
R7875 XRX.XFRONT.XFE_E.SA.n23 XRX.XFRONT.XFE_E.SA.n22 9.0005
R7876 XRX.XFRONT.XFE_E.SA.n16 XRX.XFRONT.XFE_E.SA.n5 7.17687
R7877 XRX.XFRONT.XFE_E.SA.n8 XRX.XFRONT.XFE_E.SA.n7 7.17687
R7878 XRX.XFRONT.XFE_E.SA.n1 XRX.XFRONT.XFE_E.SA.t5 5.7796
R7879 XRX.XFRONT.XFE_E.SA.n24 XRX.XFRONT.XFE_E.SA.t3 5.73764
R7880 XRX.XFRONT.XFE_E.SA.n0 XRX.XFRONT.XFE_E.SA.t0 5.73764
R7881 XRX.XFRONT.XFE_E.SA.n1 XRX.XFRONT.XFE_E.SA.t6 5.59012
R7882 XRX.XFRONT.XFE_E.SA.n0 XRX.XFRONT.XFE_E.SA.t1 5.54817
R7883 XRX.XFRONT.XFE_E.SA.n24 XRX.XFRONT.XFE_E.SA.t2 5.54817
R7884 XRX.XFRONT.XFE_E.SA.n25 XRX.XFRONT.XFE_E.SA.n24 4.73734
R7885 XRX.XFRONT.XFE_E.SA.n2 XRX.XFRONT.XFE_E.SA.n1 4.5005
R7886 XRX.XFRONT.XFE_E.SA.n16 XRX.XFRONT.XFE_E.SA.n14 4.42851
R7887 XRX.XFRONT.XFE_E.SA.n9 XRX.XFRONT.XFE_E.SA.n8 4.42851
R7888 XRX.XFRONT.XFE_E.SA XRX.XFRONT.XFE_E.SA.n26 2.50485
R7889 XRX.XFRONT.XFE_E.SA.n7 XRX.XFRONT.XFE_E.SA.n4 0.1205
R7890 XRX.XFRONT.XFE_E.SA.n12 XRX.XFRONT.XFE_E.SA.n11 0.1205
R7891 XRX.XFRONT.XFE_E.SA.n11 XRX.XFRONT.XFE_E.SA.n10 0.1205
R7892 XRX.XFRONT.XFE_E.SA.n18 XRX.XFRONT.XFE_E.SA.n17 0.1205
R7893 XRX.XFRONT.XFE_E.SA.n18 XRX.XFRONT.XFE_E.SA.n15 0.1205
R7894 XRX.XFRONT.XFE_E.SA.n21 XRX.XFRONT.XFE_E.SA.n5 0.1205
R7895 XRX.XFRONT.XFE_E.SA.n22 XRX.XFRONT.XFE_E.SA.n4 0.0485
R7896 XRX.XFRONT.XFE_E.SA.n12 XRX.XFRONT.XFE_E.SA.n3 0.0485
R7897 XRX.XFRONT.XFE_E.SA.n15 XRX.XFRONT.XFE_E.SA.n3 0.0485
R7898 XRX.XFRONT.XFE_E.SA.n22 XRX.XFRONT.XFE_E.SA.n21 0.0485
R7899 XRX.XFRONT.XFE_E.SB.n14 XRX.XFRONT.XFE_E.SB.t14 127.788
R7900 XRX.XFRONT.XFE_E.SB.n7 XRX.XFRONT.XFE_E.SB.t7 127.788
R7901 XRX.XFRONT.XFE_E.SB.t10 XRX.XFRONT.XFE_E.SB.n9 127.668
R7902 XRX.XFRONT.XFE_E.SB.n14 XRX.XFRONT.XFE_E.SB.t13 127.668
R7903 XRX.XFRONT.XFE_E.SB.t12 XRX.XFRONT.XFE_E.SB.n15 127.668
R7904 XRX.XFRONT.XFE_E.SB.n12 XRX.XFRONT.XFE_E.SB.t11 127.668
R7905 XRX.XFRONT.XFE_E.SB.n7 XRX.XFRONT.XFE_E.SB.t8 127.668
R7906 XRX.XFRONT.XFE_E.SB.n8 XRX.XFRONT.XFE_E.SB.t9 127.668
R7907 XRX.XFRONT.XFE_E.SB.t14 XRX.XFRONT.XFE_E.SB.n13 113.632
R7908 XRX.XFRONT.XFE_E.SB.n5 XRX.XFRONT.XFE_E.SB.t7 113.632
R7909 XRX.XFRONT.XFE_E.SB.n10 XRX.XFRONT.XFE_E.SB.t10 109.174
R7910 XRX.XFRONT.XFE_E.SB.t13 XRX.XFRONT.XFE_E.SB.n11 109.174
R7911 XRX.XFRONT.XFE_E.SB.n16 XRX.XFRONT.XFE_E.SB.t12 109.174
R7912 XRX.XFRONT.XFE_E.SB.n17 XRX.XFRONT.XFE_E.SB.t11 109.174
R7913 XRX.XFRONT.XFE_E.SB.t8 XRX.XFRONT.XFE_E.SB.n6 109.174
R7914 XRX.XFRONT.XFE_E.SB.t9 XRX.XFRONT.XFE_E.SB.n3 109.174
R7915 XRX.XFRONT.XFE_E.SB.n25 XRX.XFRONT.XFE_E.SB.t6 24.3193
R7916 XRX.XFRONT.XFE_E.SB.n10 XRX.XFRONT.XFE_E.SB.n1 18.4942
R7917 XRX.XFRONT.XFE_E.SB.n16 XRX.XFRONT.XFE_E.SB.n2 18.4942
R7918 XRX.XFRONT.XFE_E.SB.n18 XRX.XFRONT.XFE_E.SB.n17 18.4942
R7919 XRX.XFRONT.XFE_E.SB.n4 XRX.XFRONT.XFE_E.SB.n3 18.4942
R7920 XRX.XFRONT.XFE_E.SB.n26 XRX.XFRONT.XFE_E.SB.n25 16.5284
R7921 XRX.XFRONT.XFE_E.SB.n23 XRX.XFRONT.XFE_E.SB.n21 13.9299
R7922 XRX.XFRONT.XFE_E.SB.n17 XRX.XFRONT.XFE_E.SB.n16 11.6805
R7923 XRX.XFRONT.XFE_E.SB.n16 XRX.XFRONT.XFE_E.SB.n11 11.6805
R7924 XRX.XFRONT.XFE_E.SB.n17 XRX.XFRONT.XFE_E.SB.n10 11.6805
R7925 XRX.XFRONT.XFE_E.SB.n6 XRX.XFRONT.XFE_E.SB.n3 11.6805
R7926 XRX.XFRONT.XFE_E.SB.n10 XRX.XFRONT.XFE_E.SB.n3 11.6805
R7927 XRX.XFRONT.XFE_E.SB.n26 XRX.XFRONT.XFE_E.SB.n23 11.5728
R7928 XRX.XFRONT.XFE_E.SB.n20 XRX.XFRONT.XFE_E.SB.n0 10.8396
R7929 XRX.XFRONT.XFE_E.SB.n25 XRX.XFRONT.XFE_E.SB.n24 10.1049
R7930 XRX.XFRONT.XFE_E.SB.n20 XRX.XFRONT.XFE_E.SB.n19 9.0005
R7931 XRX.XFRONT.XFE_E.SB.n13 XRX.XFRONT.XFE_E.SB.n2 7.17687
R7932 XRX.XFRONT.XFE_E.SB.n5 XRX.XFRONT.XFE_E.SB.n4 7.17687
R7933 XRX.XFRONT.XFE_E.SB XRX.XFRONT.XFE_E.SB.n20 6.76392
R7934 XRX.XFRONT.XFE_E.SB XRX.XFRONT.XFE_E.SB.n26 6.3005
R7935 XRX.XFRONT.XFE_E.SB.n22 XRX.XFRONT.XFE_E.SB.t4 5.7796
R7936 XRX.XFRONT.XFE_E.SB.n21 XRX.XFRONT.XFE_E.SB.t1 5.73764
R7937 XRX.XFRONT.XFE_E.SB.n22 XRX.XFRONT.XFE_E.SB.t5 5.59012
R7938 XRX.XFRONT.XFE_E.SB.n21 XRX.XFRONT.XFE_E.SB.t0 5.54817
R7939 XRX.XFRONT.XFE_E.SB.n23 XRX.XFRONT.XFE_E.SB.n22 4.5005
R7940 XRX.XFRONT.XFE_E.SB.n13 XRX.XFRONT.XFE_E.SB.n11 4.42851
R7941 XRX.XFRONT.XFE_E.SB.n6 XRX.XFRONT.XFE_E.SB.n5 4.42851
R7942 XRX.XFRONT.XFE_E.SB.n24 XRX.XFRONT.XFE_E.SB.t2 0.228
R7943 XRX.XFRONT.XFE_E.SB.n24 XRX.XFRONT.XFE_E.SB.t3 0.228
R7944 XRX.XFRONT.XFE_E.SB.n4 XRX.XFRONT.XFE_E.SB.n1 0.1205
R7945 XRX.XFRONT.XFE_E.SB.n9 XRX.XFRONT.XFE_E.SB.n8 0.1205
R7946 XRX.XFRONT.XFE_E.SB.n8 XRX.XFRONT.XFE_E.SB.n7 0.1205
R7947 XRX.XFRONT.XFE_E.SB.n15 XRX.XFRONT.XFE_E.SB.n14 0.1205
R7948 XRX.XFRONT.XFE_E.SB.n15 XRX.XFRONT.XFE_E.SB.n12 0.1205
R7949 XRX.XFRONT.XFE_E.SB.n18 XRX.XFRONT.XFE_E.SB.n2 0.1205
R7950 XRX.XFRONT.XFE_E.SB.n19 XRX.XFRONT.XFE_E.SB.n1 0.0485
R7951 XRX.XFRONT.XFE_E.SB.n9 XRX.XFRONT.XFE_E.SB.n0 0.0485
R7952 XRX.XFRONT.XFE_E.SB.n12 XRX.XFRONT.XFE_E.SB.n0 0.0485
R7953 XRX.XFRONT.XFE_E.SB.n19 XRX.XFRONT.XFE_E.SB.n18 0.0485
R7954 XRX.XFRONT.XFE_E.VREGN.n14 XRX.XFRONT.XFE_E.VREGN.n6 11.1284
R7955 XRX.XFRONT.XFE_E.VREGN.n14 XRX.XFRONT.XFE_E.VREGN.n13 8.37084
R7956 XRX.XFRONT.XFE_E.VREGN.n1 XRX.XFRONT.XFE_E.VREGN.t15 5.73764
R7957 XRX.XFRONT.XFE_E.VREGN.n5 XRX.XFRONT.XFE_E.VREGN.t8 5.73764
R7958 XRX.XFRONT.XFE_E.VREGN.n9 XRX.XFRONT.XFE_E.VREGN.n7 5.51014
R7959 XRX.XFRONT.XFE_E.VREGN.n1 XRX.XFRONT.XFE_E.VREGN.n0 5.32067
R7960 XRX.XFRONT.XFE_E.VREGN.n3 XRX.XFRONT.XFE_E.VREGN.n2 5.32067
R7961 XRX.XFRONT.XFE_E.VREGN.n5 XRX.XFRONT.XFE_E.VREGN.n4 5.32067
R7962 XRX.XFRONT.XFE_E.VREGN.n9 XRX.XFRONT.XFE_E.VREGN.n8 5.32067
R7963 XRX.XFRONT.XFE_E.VREGN.n11 XRX.XFRONT.XFE_E.VREGN.n10 5.32067
R7964 XRX.XFRONT.XFE_E.VREGN.n13 XRX.XFRONT.XFE_E.VREGN.n12 5.32067
R7965 XRX.XFRONT.XFE_E.VREGN XRX.XFRONT.XFE_E.VREGN.n14 4.53963
R7966 XRX.XFRONT.XFE_E.VREGN.n7 XRX.XFRONT.XFE_E.VREGN.t6 0.228
R7967 XRX.XFRONT.XFE_E.VREGN.n7 XRX.XFRONT.XFE_E.VREGN.t7 0.228
R7968 XRX.XFRONT.XFE_E.VREGN.n0 XRX.XFRONT.XFE_E.VREGN.t13 0.228
R7969 XRX.XFRONT.XFE_E.VREGN.n0 XRX.XFRONT.XFE_E.VREGN.t14 0.228
R7970 XRX.XFRONT.XFE_E.VREGN.n2 XRX.XFRONT.XFE_E.VREGN.t11 0.228
R7971 XRX.XFRONT.XFE_E.VREGN.n2 XRX.XFRONT.XFE_E.VREGN.t12 0.228
R7972 XRX.XFRONT.XFE_E.VREGN.n4 XRX.XFRONT.XFE_E.VREGN.t9 0.228
R7973 XRX.XFRONT.XFE_E.VREGN.n4 XRX.XFRONT.XFE_E.VREGN.t10 0.228
R7974 XRX.XFRONT.XFE_E.VREGN.n8 XRX.XFRONT.XFE_E.VREGN.t4 0.228
R7975 XRX.XFRONT.XFE_E.VREGN.n8 XRX.XFRONT.XFE_E.VREGN.t5 0.228
R7976 XRX.XFRONT.XFE_E.VREGN.n10 XRX.XFRONT.XFE_E.VREGN.t2 0.228
R7977 XRX.XFRONT.XFE_E.VREGN.n10 XRX.XFRONT.XFE_E.VREGN.t3 0.228
R7978 XRX.XFRONT.XFE_E.VREGN.n12 XRX.XFRONT.XFE_E.VREGN.t0 0.228
R7979 XRX.XFRONT.XFE_E.VREGN.n12 XRX.XFRONT.XFE_E.VREGN.t1 0.228
R7980 XRX.XFRONT.XFE_E.VREGN.n13 XRX.XFRONT.XFE_E.VREGN.n11 0.189974
R7981 XRX.XFRONT.XFE_E.VREGN.n11 XRX.XFRONT.XFE_E.VREGN.n9 0.189974
R7982 XRX.XFRONT.XFE_E.VREGN.n3 XRX.XFRONT.XFE_E.VREGN.n1 0.189974
R7983 XRX.XFRONT.XFE_E.VREGN.n6 XRX.XFRONT.XFE_E.VREGN.n5 0.0952368
R7984 XRX.XFRONT.XFE_E.VREGN.n6 XRX.XFRONT.XFE_E.VREGN.n3 0.0952368
R7985 XRX.XCAP.O_RST_TAIL.n10 XRX.XCAP.O_RST_TAIL.n2 15.9369
R7986 XRX.XCAP.O_RST_TAIL.n10 XRX.XCAP.O_RST_TAIL.n9 10.957
R7987 XRX.XCAP.O_RST_TAIL.n4 XRX.XCAP.O_RST_TAIL.t7 5.7796
R7988 XRX.XCAP.O_RST_TAIL.n9 XRX.XCAP.O_RST_TAIL.t0 5.68486
R7989 XRX.XCAP.O_RST_TAIL.n2 XRX.XCAP.O_RST_TAIL.n0 5.57485
R7990 XRX.XCAP.O_RST_TAIL.n2 XRX.XCAP.O_RST_TAIL.n1 5.38537
R7991 XRX.XCAP.O_RST_TAIL.n4 XRX.XCAP.O_RST_TAIL.n3 5.38537
R7992 XRX.XCAP.O_RST_TAIL.n6 XRX.XCAP.O_RST_TAIL.n5 5.38537
R7993 XRX.XCAP.O_RST_TAIL.n8 XRX.XCAP.O_RST_TAIL.n7 5.38537
R7994 XRX.XCAP.O_RST_TAIL.n1 XRX.XCAP.O_RST_TAIL.t9 0.20525
R7995 XRX.XCAP.O_RST_TAIL.n1 XRX.XCAP.O_RST_TAIL.t8 0.20525
R7996 XRX.XCAP.O_RST_TAIL.n0 XRX.XCAP.O_RST_TAIL.t11 0.20525
R7997 XRX.XCAP.O_RST_TAIL.n0 XRX.XCAP.O_RST_TAIL.t10 0.20525
R7998 XRX.XCAP.O_RST_TAIL.n3 XRX.XCAP.O_RST_TAIL.t5 0.20525
R7999 XRX.XCAP.O_RST_TAIL.n3 XRX.XCAP.O_RST_TAIL.t6 0.20525
R8000 XRX.XCAP.O_RST_TAIL.n5 XRX.XCAP.O_RST_TAIL.t3 0.20525
R8001 XRX.XCAP.O_RST_TAIL.n5 XRX.XCAP.O_RST_TAIL.t4 0.20525
R8002 XRX.XCAP.O_RST_TAIL.n7 XRX.XCAP.O_RST_TAIL.t1 0.20525
R8003 XRX.XCAP.O_RST_TAIL.n7 XRX.XCAP.O_RST_TAIL.t2 0.20525
R8004 XRX.XCAP.O_RST_TAIL.n8 XRX.XCAP.O_RST_TAIL.n6 0.189974
R8005 XRX.XCAP.O_RST_TAIL.n6 XRX.XCAP.O_RST_TAIL.n4 0.189974
R8006 XRX.XCAP.O_RST_TAIL.n9 XRX.XCAP.O_RST_TAIL.n8 0.0952368
R8007 XRX.XCAP.O_RST_TAIL XRX.XCAP.O_RST_TAIL.n10 0.0396304
R8008 XRX.XCAP.E_RST_TAIL.n10 XRX.XCAP.E_RST_TAIL.n9 11.9456
R8009 XRX.XCAP.E_RST_TAIL.n10 XRX.XCAP.E_RST_TAIL.n6 11.6614
R8010 XRX.XCAP.E_RST_TAIL.n1 XRX.XCAP.E_RST_TAIL.t11 5.7796
R8011 XRX.XCAP.E_RST_TAIL.n6 XRX.XCAP.E_RST_TAIL.t4 5.68486
R8012 XRX.XCAP.E_RST_TAIL.n9 XRX.XCAP.E_RST_TAIL.n7 5.57485
R8013 XRX.XCAP.E_RST_TAIL.n1 XRX.XCAP.E_RST_TAIL.n0 5.38537
R8014 XRX.XCAP.E_RST_TAIL.n9 XRX.XCAP.E_RST_TAIL.n8 5.38537
R8015 XRX.XCAP.E_RST_TAIL.n3 XRX.XCAP.E_RST_TAIL.n2 5.38537
R8016 XRX.XCAP.E_RST_TAIL.n5 XRX.XCAP.E_RST_TAIL.n4 5.38537
R8017 XRX.XCAP.E_RST_TAIL.n0 XRX.XCAP.E_RST_TAIL.t9 0.20525
R8018 XRX.XCAP.E_RST_TAIL.n0 XRX.XCAP.E_RST_TAIL.t10 0.20525
R8019 XRX.XCAP.E_RST_TAIL.n8 XRX.XCAP.E_RST_TAIL.t2 0.20525
R8020 XRX.XCAP.E_RST_TAIL.n8 XRX.XCAP.E_RST_TAIL.t1 0.20525
R8021 XRX.XCAP.E_RST_TAIL.n7 XRX.XCAP.E_RST_TAIL.t0 0.20525
R8022 XRX.XCAP.E_RST_TAIL.n7 XRX.XCAP.E_RST_TAIL.t3 0.20525
R8023 XRX.XCAP.E_RST_TAIL.n2 XRX.XCAP.E_RST_TAIL.t7 0.20525
R8024 XRX.XCAP.E_RST_TAIL.n2 XRX.XCAP.E_RST_TAIL.t8 0.20525
R8025 XRX.XCAP.E_RST_TAIL.n4 XRX.XCAP.E_RST_TAIL.t5 0.20525
R8026 XRX.XCAP.E_RST_TAIL.n4 XRX.XCAP.E_RST_TAIL.t6 0.20525
R8027 XRX.XCAP.E_RST_TAIL.n5 XRX.XCAP.E_RST_TAIL.n3 0.189974
R8028 XRX.XCAP.E_RST_TAIL.n3 XRX.XCAP.E_RST_TAIL.n1 0.189974
R8029 XRX.XCAP.E_RST_TAIL.n6 XRX.XCAP.E_RST_TAIL.n5 0.0952368
R8030 XRX.XCAP.E_RST_TAIL XRX.XCAP.E_RST_TAIL.n10 0.0396304
R8031 XRX.XCAP.O_SET_TAIL.n9 XRX.XCAP.O_SET_TAIL.n5 11.3875
R8032 XRX.XCAP.O_SET_TAIL.n9 XRX.XCAP.O_SET_TAIL.n8 9.68219
R8033 XRX.XCAP.O_SET_TAIL.n1 XRX.XCAP.O_SET_TAIL.t7 5.7796
R8034 XRX.XCAP.O_SET_TAIL.n5 XRX.XCAP.O_SET_TAIL.t0 5.7796
R8035 XRX.XCAP.O_SET_TAIL.n8 XRX.XCAP.O_SET_TAIL.n6 5.57485
R8036 XRX.XCAP.O_SET_TAIL.n1 XRX.XCAP.O_SET_TAIL.n0 5.38537
R8037 XRX.XCAP.O_SET_TAIL.n3 XRX.XCAP.O_SET_TAIL.n2 5.38537
R8038 XRX.XCAP.O_SET_TAIL.n8 XRX.XCAP.O_SET_TAIL.n7 5.38537
R8039 XRX.XCAP.O_SET_TAIL.n5 XRX.XCAP.O_SET_TAIL.n4 5.38537
R8040 XRX.XCAP.O_SET_TAIL.n0 XRX.XCAP.O_SET_TAIL.t5 0.20525
R8041 XRX.XCAP.O_SET_TAIL.n0 XRX.XCAP.O_SET_TAIL.t6 0.20525
R8042 XRX.XCAP.O_SET_TAIL.n2 XRX.XCAP.O_SET_TAIL.t3 0.20525
R8043 XRX.XCAP.O_SET_TAIL.n2 XRX.XCAP.O_SET_TAIL.t4 0.20525
R8044 XRX.XCAP.O_SET_TAIL.n7 XRX.XCAP.O_SET_TAIL.t10 0.20525
R8045 XRX.XCAP.O_SET_TAIL.n7 XRX.XCAP.O_SET_TAIL.t9 0.20525
R8046 XRX.XCAP.O_SET_TAIL.n6 XRX.XCAP.O_SET_TAIL.t8 0.20525
R8047 XRX.XCAP.O_SET_TAIL.n6 XRX.XCAP.O_SET_TAIL.t11 0.20525
R8048 XRX.XCAP.O_SET_TAIL.n4 XRX.XCAP.O_SET_TAIL.t1 0.20525
R8049 XRX.XCAP.O_SET_TAIL.n4 XRX.XCAP.O_SET_TAIL.t2 0.20525
R8050 XRX.XCAP.O_SET_TAIL.n5 XRX.XCAP.O_SET_TAIL.n3 0.189974
R8051 XRX.XCAP.O_SET_TAIL.n3 XRX.XCAP.O_SET_TAIL.n1 0.189974
R8052 XRX.XCAP.O_SET_TAIL XRX.XCAP.O_SET_TAIL.n9 0.0396304
R8053 XRX.XCAP.E_SET_TAIL.n9 XRX.XCAP.E_SET_TAIL.n2 12.1083
R8054 XRX.XCAP.E_SET_TAIL.n9 XRX.XCAP.E_SET_TAIL.n8 10.2135
R8055 XRX.XCAP.E_SET_TAIL.n4 XRX.XCAP.E_SET_TAIL.t11 5.7796
R8056 XRX.XCAP.E_SET_TAIL.n8 XRX.XCAP.E_SET_TAIL.t4 5.7796
R8057 XRX.XCAP.E_SET_TAIL.n2 XRX.XCAP.E_SET_TAIL.n0 5.57485
R8058 XRX.XCAP.E_SET_TAIL.n4 XRX.XCAP.E_SET_TAIL.n3 5.38537
R8059 XRX.XCAP.E_SET_TAIL.n6 XRX.XCAP.E_SET_TAIL.n5 5.38537
R8060 XRX.XCAP.E_SET_TAIL.n2 XRX.XCAP.E_SET_TAIL.n1 5.38537
R8061 XRX.XCAP.E_SET_TAIL.n8 XRX.XCAP.E_SET_TAIL.n7 5.38537
R8062 XRX.XCAP.E_SET_TAIL.n3 XRX.XCAP.E_SET_TAIL.t9 0.20525
R8063 XRX.XCAP.E_SET_TAIL.n3 XRX.XCAP.E_SET_TAIL.t10 0.20525
R8064 XRX.XCAP.E_SET_TAIL.n5 XRX.XCAP.E_SET_TAIL.t7 0.20525
R8065 XRX.XCAP.E_SET_TAIL.n5 XRX.XCAP.E_SET_TAIL.t8 0.20525
R8066 XRX.XCAP.E_SET_TAIL.n1 XRX.XCAP.E_SET_TAIL.t1 0.20525
R8067 XRX.XCAP.E_SET_TAIL.n1 XRX.XCAP.E_SET_TAIL.t0 0.20525
R8068 XRX.XCAP.E_SET_TAIL.n0 XRX.XCAP.E_SET_TAIL.t3 0.20525
R8069 XRX.XCAP.E_SET_TAIL.n0 XRX.XCAP.E_SET_TAIL.t2 0.20525
R8070 XRX.XCAP.E_SET_TAIL.n7 XRX.XCAP.E_SET_TAIL.t5 0.20525
R8071 XRX.XCAP.E_SET_TAIL.n7 XRX.XCAP.E_SET_TAIL.t6 0.20525
R8072 XRX.XCAP.E_SET_TAIL.n8 XRX.XCAP.E_SET_TAIL.n6 0.189974
R8073 XRX.XCAP.E_SET_TAIL.n6 XRX.XCAP.E_SET_TAIL.n4 0.189974
R8074 XRX.XCAP.E_SET_TAIL XRX.XCAP.E_SET_TAIL.n9 0.0396304
R8075 XRX.XCAP.O_PSET_TAIL.n10 XRX.XCAP.O_PSET_TAIL.n2 15.7351
R8076 XRX.XCAP.O_PSET_TAIL.n10 XRX.XCAP.O_PSET_TAIL.n9 12.6005
R8077 XRX.XCAP.O_PSET_TAIL.n4 XRX.XCAP.O_PSET_TAIL.t11 5.73764
R8078 XRX.XCAP.O_PSET_TAIL.n9 XRX.XCAP.O_PSET_TAIL.t4 5.54817
R8079 XRX.XCAP.O_PSET_TAIL.n2 XRX.XCAP.O_PSET_TAIL.n0 5.51014
R8080 XRX.XCAP.O_PSET_TAIL.n4 XRX.XCAP.O_PSET_TAIL.n3 5.32067
R8081 XRX.XCAP.O_PSET_TAIL.n6 XRX.XCAP.O_PSET_TAIL.n5 5.32067
R8082 XRX.XCAP.O_PSET_TAIL.n8 XRX.XCAP.O_PSET_TAIL.n7 5.32067
R8083 XRX.XCAP.O_PSET_TAIL.n2 XRX.XCAP.O_PSET_TAIL.n1 5.32067
R8084 XRX.XCAP.O_PSET_TAIL.n3 XRX.XCAP.O_PSET_TAIL.t9 0.228
R8085 XRX.XCAP.O_PSET_TAIL.n3 XRX.XCAP.O_PSET_TAIL.t10 0.228
R8086 XRX.XCAP.O_PSET_TAIL.n5 XRX.XCAP.O_PSET_TAIL.t7 0.228
R8087 XRX.XCAP.O_PSET_TAIL.n5 XRX.XCAP.O_PSET_TAIL.t8 0.228
R8088 XRX.XCAP.O_PSET_TAIL.n7 XRX.XCAP.O_PSET_TAIL.t5 0.228
R8089 XRX.XCAP.O_PSET_TAIL.n7 XRX.XCAP.O_PSET_TAIL.t6 0.228
R8090 XRX.XCAP.O_PSET_TAIL.n1 XRX.XCAP.O_PSET_TAIL.t3 0.228
R8091 XRX.XCAP.O_PSET_TAIL.n1 XRX.XCAP.O_PSET_TAIL.t2 0.228
R8092 XRX.XCAP.O_PSET_TAIL.n0 XRX.XCAP.O_PSET_TAIL.t1 0.228
R8093 XRX.XCAP.O_PSET_TAIL.n0 XRX.XCAP.O_PSET_TAIL.t0 0.228
R8094 XRX.XCAP.O_PSET_TAIL.n9 XRX.XCAP.O_PSET_TAIL.n8 0.189974
R8095 XRX.XCAP.O_PSET_TAIL.n8 XRX.XCAP.O_PSET_TAIL.n6 0.189974
R8096 XRX.XCAP.O_PSET_TAIL.n6 XRX.XCAP.O_PSET_TAIL.n4 0.189974
R8097 XRX.XCAP.O_PSET_TAIL XRX.XCAP.O_PSET_TAIL.n10 0.0396304
R8098 XRX.XCAP.E_PSET_TAIL.n10 XRX.XCAP.E_PSET_TAIL.n6 15.4962
R8099 XRX.XCAP.E_PSET_TAIL.n10 XRX.XCAP.E_PSET_TAIL.n9 12.1804
R8100 XRX.XCAP.E_PSET_TAIL.n1 XRX.XCAP.E_PSET_TAIL.t11 5.73764
R8101 XRX.XCAP.E_PSET_TAIL.n6 XRX.XCAP.E_PSET_TAIL.t4 5.54817
R8102 XRX.XCAP.E_PSET_TAIL.n9 XRX.XCAP.E_PSET_TAIL.n7 5.51014
R8103 XRX.XCAP.E_PSET_TAIL.n1 XRX.XCAP.E_PSET_TAIL.n0 5.32067
R8104 XRX.XCAP.E_PSET_TAIL.n3 XRX.XCAP.E_PSET_TAIL.n2 5.32067
R8105 XRX.XCAP.E_PSET_TAIL.n5 XRX.XCAP.E_PSET_TAIL.n4 5.32067
R8106 XRX.XCAP.E_PSET_TAIL.n9 XRX.XCAP.E_PSET_TAIL.n8 5.32067
R8107 XRX.XCAP.E_PSET_TAIL.n0 XRX.XCAP.E_PSET_TAIL.t9 0.228
R8108 XRX.XCAP.E_PSET_TAIL.n0 XRX.XCAP.E_PSET_TAIL.t10 0.228
R8109 XRX.XCAP.E_PSET_TAIL.n2 XRX.XCAP.E_PSET_TAIL.t7 0.228
R8110 XRX.XCAP.E_PSET_TAIL.n2 XRX.XCAP.E_PSET_TAIL.t8 0.228
R8111 XRX.XCAP.E_PSET_TAIL.n4 XRX.XCAP.E_PSET_TAIL.t5 0.228
R8112 XRX.XCAP.E_PSET_TAIL.n4 XRX.XCAP.E_PSET_TAIL.t6 0.228
R8113 XRX.XCAP.E_PSET_TAIL.n7 XRX.XCAP.E_PSET_TAIL.t1 0.228
R8114 XRX.XCAP.E_PSET_TAIL.n7 XRX.XCAP.E_PSET_TAIL.t0 0.228
R8115 XRX.XCAP.E_PSET_TAIL.n8 XRX.XCAP.E_PSET_TAIL.t3 0.228
R8116 XRX.XCAP.E_PSET_TAIL.n8 XRX.XCAP.E_PSET_TAIL.t2 0.228
R8117 XRX.XCAP.E_PSET_TAIL.n6 XRX.XCAP.E_PSET_TAIL.n5 0.189974
R8118 XRX.XCAP.E_PSET_TAIL.n5 XRX.XCAP.E_PSET_TAIL.n3 0.189974
R8119 XRX.XCAP.E_PSET_TAIL.n3 XRX.XCAP.E_PSET_TAIL.n1 0.189974
R8120 XRX.XCAP.E_PSET_TAIL XRX.XCAP.E_PSET_TAIL.n10 0.0396304
R8121 XRX.XCAP.O_QI.n0 XRX.XCAP.O_QI.t19 113.632
R8122 XRX.XCAP.O_QI.n16 XRX.XCAP.O_QI.t12 113.618
R8123 XRX.XCAP.O_QI.n16 XRX.XCAP.O_QI.t13 113.618
R8124 XRX.XCAP.O_QI.n15 XRX.XCAP.O_QI.t16 113.618
R8125 XRX.XCAP.O_QI.n15 XRX.XCAP.O_QI.t17 113.618
R8126 XRX.XCAP.O_QI.n0 XRX.XCAP.O_QI.t18 113.603
R8127 XRX.XCAP.O_QI.n1 XRX.XCAP.O_QI.t15 61.4885
R8128 XRX.XCAP.O_QI.n1 XRX.XCAP.O_QI.t14 61.4598
R8129 XRX.XCAP.O_QI.n2 XRX.XCAP.O_QI.n0 21.3118
R8130 XRX.XCAP.O_QI.n17 XRX.XCAP.O_QI.n15 19.4852
R8131 XRX.XCAP.O_QI.n17 XRX.XCAP.O_QI.n16 17.5287
R8132 XRX.XCAP.O_QI.n2 XRX.XCAP.O_QI.n1 16.2249
R8133 XRX.XCAP.O_QI.n14 XRX.XCAP.O_QI.n2 10.9375
R8134 XRX.XCAP.O_QI.n13 XRX.XCAP.O_QI.n12 9.70485
R8135 XRX.XCAP.O_QI.n7 XRX.XCAP.O_QI.n5 7.43528
R8136 XRX.XCAP.O_QI.n11 XRX.XCAP.O_QI.t1 5.7796
R8137 XRX.XCAP.O_QI.n8 XRX.XCAP.O_QI.t10 5.7796
R8138 XRX.XCAP.O_QI.n6 XRX.XCAP.O_QI.t11 5.73764
R8139 XRX.XCAP.O_QI.n4 XRX.XCAP.O_QI.t7 5.73764
R8140 XRX.XCAP.O_QI.n12 XRX.XCAP.O_QI.t6 5.68486
R8141 XRX.XCAP.O_QI.n5 XRX.XCAP.O_QI.t5 5.6429
R8142 XRX.XCAP.O_QI.n8 XRX.XCAP.O_QI.t9 5.59012
R8143 XRX.XCAP.O_QI.n6 XRX.XCAP.O_QI.t0 5.54817
R8144 XRX.XCAP.O_QI.n11 XRX.XCAP.O_QI.n10 5.38537
R8145 XRX.XCAP.O_QI.n4 XRX.XCAP.O_QI.n3 5.32067
R8146 XRX.XCAP.O_QI.n9 XRX.XCAP.O_QI.n7 4.8918
R8147 XRX.XCAP.O_QI.n7 XRX.XCAP.O_QI.n6 4.5005
R8148 XRX.XCAP.O_QI.n9 XRX.XCAP.O_QI.n8 4.5005
R8149 XRX.XCAP.O_QI.n14 XRX.XCAP.O_QI.n13 4.5005
R8150 XRX.XCAP.O_QI.n18 XRX.XCAP.O_QI.n17 4.5005
R8151 XRX.XCAP.O_QI.n18 XRX.XCAP.O_QI.n14 2.1918
R8152 XRX.XCAP.O_QI.n3 XRX.XCAP.O_QI.t4 0.228
R8153 XRX.XCAP.O_QI.n3 XRX.XCAP.O_QI.t8 0.228
R8154 XRX.XCAP.O_QI.n10 XRX.XCAP.O_QI.t3 0.20525
R8155 XRX.XCAP.O_QI.n10 XRX.XCAP.O_QI.t2 0.20525
R8156 XRX.XCAP.O_QI.n12 XRX.XCAP.O_QI.n11 0.0952368
R8157 XRX.XCAP.O_QI.n5 XRX.XCAP.O_QI.n4 0.0952368
R8158 XRX.XCAP.O_QI.n13 XRX.XCAP.O_QI.n9 0.0787609
R8159 XRX.XCAP.O_QI XRX.XCAP.O_QI.n18 0.0396304
R8160 XRX.XCAP.ODD_DB_BUF.n18 XRX.XCAP.ODD_DB_BUF.t12 113.632
R8161 XRX.XCAP.ODD_DB_BUF.n12 XRX.XCAP.ODD_DB_BUF.t16 113.632
R8162 XRX.XCAP.ODD_DB_BUF.n21 XRX.XCAP.ODD_DB_BUF.t15 109.174
R8163 XRX.XCAP.ODD_DB_BUF.n20 XRX.XCAP.ODD_DB_BUF.t14 109.174
R8164 XRX.XCAP.ODD_DB_BUF.n19 XRX.XCAP.ODD_DB_BUF.t13 109.174
R8165 XRX.XCAP.ODD_DB_BUF.n13 XRX.XCAP.ODD_DB_BUF.t17 109.174
R8166 XRX.XCAP.ODD_DB_BUF.n14 XRX.XCAP.ODD_DB_BUF.t18 109.174
R8167 XRX.XCAP.ODD_DB_BUF.n15 XRX.XCAP.ODD_DB_BUF.t19 109.174
R8168 XRX.XCAP.ODD_DB_BUF.n23 XRX.XCAP.ODD_DB_BUF.n22 21.6707
R8169 XRX.XCAP.ODD_DB_BUF.n22 XRX.XCAP.ODD_DB_BUF.n21 18.4942
R8170 XRX.XCAP.ODD_DB_BUF.n20 XRX.XCAP.ODD_DB_BUF.n17 18.4942
R8171 XRX.XCAP.ODD_DB_BUF.n14 XRX.XCAP.ODD_DB_BUF.n11 18.4942
R8172 XRX.XCAP.ODD_DB_BUF.n16 XRX.XCAP.ODD_DB_BUF.n15 18.4942
R8173 XRX.XCAP.ODD_DB_BUF.n21 XRX.XCAP.ODD_DB_BUF.n20 11.6805
R8174 XRX.XCAP.ODD_DB_BUF.n20 XRX.XCAP.ODD_DB_BUF.n19 11.6805
R8175 XRX.XCAP.ODD_DB_BUF.n14 XRX.XCAP.ODD_DB_BUF.n13 11.6805
R8176 XRX.XCAP.ODD_DB_BUF.n15 XRX.XCAP.ODD_DB_BUF.n14 11.6805
R8177 XRX.XCAP.ODD_DB_BUF.n10 XRX.XCAP.ODD_DB_BUF.n2 10.3701
R8178 XRX.XCAP.ODD_DB_BUF.n23 XRX.XCAP.ODD_DB_BUF.n16 9.77502
R8179 XRX.XCAP.ODD_DB_BUF.n24 XRX.XCAP.ODD_DB_BUF.n10 7.94398
R8180 XRX.XCAP.ODD_DB_BUF.n18 XRX.XCAP.ODD_DB_BUF.n17 7.17687
R8181 XRX.XCAP.ODD_DB_BUF.n12 XRX.XCAP.ODD_DB_BUF.n11 7.17687
R8182 XRX.XCAP.ODD_DB_BUF.n1 XRX.XCAP.ODD_DB_BUF.t11 5.7796
R8183 XRX.XCAP.ODD_DB_BUF.n4 XRX.XCAP.ODD_DB_BUF.t7 5.73764
R8184 XRX.XCAP.ODD_DB_BUF.n8 XRX.XCAP.ODD_DB_BUF.t0 5.73764
R8185 XRX.XCAP.ODD_DB_BUF.n2 XRX.XCAP.ODD_DB_BUF.t8 5.68486
R8186 XRX.XCAP.ODD_DB_BUF.n1 XRX.XCAP.ODD_DB_BUF.n0 5.38537
R8187 XRX.XCAP.ODD_DB_BUF.n4 XRX.XCAP.ODD_DB_BUF.n3 5.32067
R8188 XRX.XCAP.ODD_DB_BUF.n6 XRX.XCAP.ODD_DB_BUF.n5 5.32067
R8189 XRX.XCAP.ODD_DB_BUF.n8 XRX.XCAP.ODD_DB_BUF.n7 5.32067
R8190 XRX.XCAP.ODD_DB_BUF.n10 XRX.XCAP.ODD_DB_BUF.n9 4.5005
R8191 XRX.XCAP.ODD_DB_BUF.n24 XRX.XCAP.ODD_DB_BUF.n23 4.5005
R8192 XRX.XCAP.ODD_DB_BUF.n19 XRX.XCAP.ODD_DB_BUF.n18 4.42851
R8193 XRX.XCAP.ODD_DB_BUF.n13 XRX.XCAP.ODD_DB_BUF.n12 4.42851
R8194 XRX.XCAP.ODD_DB_BUF.n3 XRX.XCAP.ODD_DB_BUF.t5 0.228
R8195 XRX.XCAP.ODD_DB_BUF.n3 XRX.XCAP.ODD_DB_BUF.t6 0.228
R8196 XRX.XCAP.ODD_DB_BUF.n5 XRX.XCAP.ODD_DB_BUF.t3 0.228
R8197 XRX.XCAP.ODD_DB_BUF.n5 XRX.XCAP.ODD_DB_BUF.t4 0.228
R8198 XRX.XCAP.ODD_DB_BUF.n7 XRX.XCAP.ODD_DB_BUF.t1 0.228
R8199 XRX.XCAP.ODD_DB_BUF.n7 XRX.XCAP.ODD_DB_BUF.t2 0.228
R8200 XRX.XCAP.ODD_DB_BUF.n0 XRX.XCAP.ODD_DB_BUF.t9 0.20525
R8201 XRX.XCAP.ODD_DB_BUF.n0 XRX.XCAP.ODD_DB_BUF.t10 0.20525
R8202 XRX.XCAP.ODD_DB_BUF.n6 XRX.XCAP.ODD_DB_BUF.n4 0.189974
R8203 XRX.XCAP.ODD_DB_BUF.n22 XRX.XCAP.ODD_DB_BUF.n17 0.1205
R8204 XRX.XCAP.ODD_DB_BUF.n16 XRX.XCAP.ODD_DB_BUF.n11 0.1205
R8205 XRX.XCAP.ODD_DB_BUF.n9 XRX.XCAP.ODD_DB_BUF.n8 0.0952368
R8206 XRX.XCAP.ODD_DB_BUF.n9 XRX.XCAP.ODD_DB_BUF.n6 0.0952368
R8207 XRX.XCAP.ODD_DB_BUF.n2 XRX.XCAP.ODD_DB_BUF.n1 0.0952368
R8208 XRX.XCAP.ODD_DB_BUF XRX.XCAP.ODD_DB_BUF.n24 0.0396304
R8209 XRX.XCAP.EVEN_DB_BUF.n7 XRX.XCAP.EVEN_DB_BUF.t12 113.632
R8210 XRX.XCAP.EVEN_DB_BUF.n1 XRX.XCAP.EVEN_DB_BUF.t16 113.632
R8211 XRX.XCAP.EVEN_DB_BUF.n10 XRX.XCAP.EVEN_DB_BUF.t15 109.174
R8212 XRX.XCAP.EVEN_DB_BUF.n9 XRX.XCAP.EVEN_DB_BUF.t14 109.174
R8213 XRX.XCAP.EVEN_DB_BUF.n8 XRX.XCAP.EVEN_DB_BUF.t13 109.174
R8214 XRX.XCAP.EVEN_DB_BUF.n2 XRX.XCAP.EVEN_DB_BUF.t17 109.174
R8215 XRX.XCAP.EVEN_DB_BUF.n3 XRX.XCAP.EVEN_DB_BUF.t18 109.174
R8216 XRX.XCAP.EVEN_DB_BUF.n4 XRX.XCAP.EVEN_DB_BUF.t19 109.174
R8217 XRX.XCAP.EVEN_DB_BUF.n12 XRX.XCAP.EVEN_DB_BUF.n11 21.1228
R8218 XRX.XCAP.EVEN_DB_BUF.n11 XRX.XCAP.EVEN_DB_BUF.n10 18.4942
R8219 XRX.XCAP.EVEN_DB_BUF.n9 XRX.XCAP.EVEN_DB_BUF.n6 18.4942
R8220 XRX.XCAP.EVEN_DB_BUF.n3 XRX.XCAP.EVEN_DB_BUF.n0 18.4942
R8221 XRX.XCAP.EVEN_DB_BUF.n5 XRX.XCAP.EVEN_DB_BUF.n4 18.4942
R8222 XRX.XCAP.EVEN_DB_BUF.n10 XRX.XCAP.EVEN_DB_BUF.n9 11.6805
R8223 XRX.XCAP.EVEN_DB_BUF.n9 XRX.XCAP.EVEN_DB_BUF.n8 11.6805
R8224 XRX.XCAP.EVEN_DB_BUF.n3 XRX.XCAP.EVEN_DB_BUF.n2 11.6805
R8225 XRX.XCAP.EVEN_DB_BUF.n4 XRX.XCAP.EVEN_DB_BUF.n3 11.6805
R8226 XRX.XCAP.EVEN_DB_BUF.n23 XRX.XCAP.EVEN_DB_BUF.n15 10.3701
R8227 XRX.XCAP.EVEN_DB_BUF.n12 XRX.XCAP.EVEN_DB_BUF.n5 10.3228
R8228 XRX.XCAP.EVEN_DB_BUF.n7 XRX.XCAP.EVEN_DB_BUF.n6 7.17687
R8229 XRX.XCAP.EVEN_DB_BUF.n1 XRX.XCAP.EVEN_DB_BUF.n0 7.17687
R8230 XRX.XCAP.EVEN_DB_BUF.n24 XRX.XCAP.EVEN_DB_BUF.n12 6.53528
R8231 XRX.XCAP.EVEN_DB_BUF.n14 XRX.XCAP.EVEN_DB_BUF.t11 5.7796
R8232 XRX.XCAP.EVEN_DB_BUF.n17 XRX.XCAP.EVEN_DB_BUF.t7 5.73764
R8233 XRX.XCAP.EVEN_DB_BUF.n21 XRX.XCAP.EVEN_DB_BUF.t0 5.73764
R8234 XRX.XCAP.EVEN_DB_BUF.n15 XRX.XCAP.EVEN_DB_BUF.t8 5.68486
R8235 XRX.XCAP.EVEN_DB_BUF.n14 XRX.XCAP.EVEN_DB_BUF.n13 5.38537
R8236 XRX.XCAP.EVEN_DB_BUF.n17 XRX.XCAP.EVEN_DB_BUF.n16 5.32067
R8237 XRX.XCAP.EVEN_DB_BUF.n19 XRX.XCAP.EVEN_DB_BUF.n18 5.32067
R8238 XRX.XCAP.EVEN_DB_BUF.n21 XRX.XCAP.EVEN_DB_BUF.n20 5.32067
R8239 XRX.XCAP.EVEN_DB_BUF.n24 XRX.XCAP.EVEN_DB_BUF.n23 4.73528
R8240 XRX.XCAP.EVEN_DB_BUF.n23 XRX.XCAP.EVEN_DB_BUF.n22 4.5005
R8241 XRX.XCAP.EVEN_DB_BUF.n8 XRX.XCAP.EVEN_DB_BUF.n7 4.42851
R8242 XRX.XCAP.EVEN_DB_BUF.n2 XRX.XCAP.EVEN_DB_BUF.n1 4.42851
R8243 XRX.XCAP.EVEN_DB_BUF.n16 XRX.XCAP.EVEN_DB_BUF.t5 0.228
R8244 XRX.XCAP.EVEN_DB_BUF.n16 XRX.XCAP.EVEN_DB_BUF.t6 0.228
R8245 XRX.XCAP.EVEN_DB_BUF.n18 XRX.XCAP.EVEN_DB_BUF.t3 0.228
R8246 XRX.XCAP.EVEN_DB_BUF.n18 XRX.XCAP.EVEN_DB_BUF.t4 0.228
R8247 XRX.XCAP.EVEN_DB_BUF.n20 XRX.XCAP.EVEN_DB_BUF.t1 0.228
R8248 XRX.XCAP.EVEN_DB_BUF.n20 XRX.XCAP.EVEN_DB_BUF.t2 0.228
R8249 XRX.XCAP.EVEN_DB_BUF.n13 XRX.XCAP.EVEN_DB_BUF.t9 0.20525
R8250 XRX.XCAP.EVEN_DB_BUF.n13 XRX.XCAP.EVEN_DB_BUF.t10 0.20525
R8251 XRX.XCAP.EVEN_DB_BUF.n19 XRX.XCAP.EVEN_DB_BUF.n17 0.189974
R8252 XRX.XCAP.EVEN_DB_BUF.n11 XRX.XCAP.EVEN_DB_BUF.n6 0.1205
R8253 XRX.XCAP.EVEN_DB_BUF.n5 XRX.XCAP.EVEN_DB_BUF.n0 0.1205
R8254 XRX.XCAP.EVEN_DB_BUF.n22 XRX.XCAP.EVEN_DB_BUF.n21 0.0952368
R8255 XRX.XCAP.EVEN_DB_BUF.n22 XRX.XCAP.EVEN_DB_BUF.n19 0.0952368
R8256 XRX.XCAP.EVEN_DB_BUF.n15 XRX.XCAP.EVEN_DB_BUF.n14 0.0952368
R8257 XRX.XCAP.EVEN_DB_BUF XRX.XCAP.EVEN_DB_BUF.n24 0.0396304
R8258 XRX.XCAP.E_QI.n15 XRX.XCAP.E_QI.t19 113.632
R8259 XRX.XCAP.E_QI.n1 XRX.XCAP.E_QI.t12 113.618
R8260 XRX.XCAP.E_QI.n1 XRX.XCAP.E_QI.t13 113.618
R8261 XRX.XCAP.E_QI.n0 XRX.XCAP.E_QI.t16 113.618
R8262 XRX.XCAP.E_QI.n0 XRX.XCAP.E_QI.t17 113.618
R8263 XRX.XCAP.E_QI.n15 XRX.XCAP.E_QI.t18 113.603
R8264 XRX.XCAP.E_QI.n16 XRX.XCAP.E_QI.t15 61.4885
R8265 XRX.XCAP.E_QI.n16 XRX.XCAP.E_QI.t14 61.4598
R8266 XRX.XCAP.E_QI.n17 XRX.XCAP.E_QI.n15 21.3118
R8267 XRX.XCAP.E_QI.n2 XRX.XCAP.E_QI.n0 20.0331
R8268 XRX.XCAP.E_QI.n2 XRX.XCAP.E_QI.n1 16.9809
R8269 XRX.XCAP.E_QI.n17 XRX.XCAP.E_QI.n16 16.2249
R8270 XRX.XCAP.E_QI.n13 XRX.XCAP.E_QI.n12 9.15702
R8271 XRX.XCAP.E_QI.n7 XRX.XCAP.E_QI.n5 7.43528
R8272 XRX.XCAP.E_QI.n14 XRX.XCAP.E_QI.n2 7.00485
R8273 XRX.XCAP.E_QI.n18 XRX.XCAP.E_QI.n17 6.32007
R8274 XRX.XCAP.E_QI.n11 XRX.XCAP.E_QI.t11 5.7796
R8275 XRX.XCAP.E_QI.n8 XRX.XCAP.E_QI.t0 5.7796
R8276 XRX.XCAP.E_QI.n4 XRX.XCAP.E_QI.t7 5.73764
R8277 XRX.XCAP.E_QI.n6 XRX.XCAP.E_QI.t2 5.73764
R8278 XRX.XCAP.E_QI.n12 XRX.XCAP.E_QI.t8 5.68486
R8279 XRX.XCAP.E_QI.n5 XRX.XCAP.E_QI.t4 5.6429
R8280 XRX.XCAP.E_QI.n8 XRX.XCAP.E_QI.t1 5.59012
R8281 XRX.XCAP.E_QI.n6 XRX.XCAP.E_QI.t3 5.54817
R8282 XRX.XCAP.E_QI.n11 XRX.XCAP.E_QI.n10 5.38537
R8283 XRX.XCAP.E_QI.n4 XRX.XCAP.E_QI.n3 5.32067
R8284 XRX.XCAP.E_QI.n9 XRX.XCAP.E_QI.n7 4.8918
R8285 XRX.XCAP.E_QI.n7 XRX.XCAP.E_QI.n6 4.5005
R8286 XRX.XCAP.E_QI.n9 XRX.XCAP.E_QI.n8 4.5005
R8287 XRX.XCAP.E_QI.n14 XRX.XCAP.E_QI.n13 4.5005
R8288 XRX.XCAP.E_QI.n18 XRX.XCAP.E_QI.n14 4.22659
R8289 XRX.XCAP.E_QI.n13 XRX.XCAP.E_QI.n9 0.626587
R8290 XRX.XCAP.E_QI.n3 XRX.XCAP.E_QI.t5 0.228
R8291 XRX.XCAP.E_QI.n3 XRX.XCAP.E_QI.t6 0.228
R8292 XRX.XCAP.E_QI.n10 XRX.XCAP.E_QI.t9 0.20525
R8293 XRX.XCAP.E_QI.n10 XRX.XCAP.E_QI.t10 0.20525
R8294 XRX.XCAP.E_QI.n5 XRX.XCAP.E_QI.n4 0.0952368
R8295 XRX.XCAP.E_QI.n12 XRX.XCAP.E_QI.n11 0.0952368
R8296 XRX.XCAP.E_QI XRX.XCAP.E_QI.n18 0.0396304
R8297 XRX.XCAP.O_QBBUF.n0 XRX.XCAP.O_QBBUF.t7 113.632
R8298 XRX.XCAP.O_QBBUF.n3 XRX.XCAP.O_QBBUF.t10 113.632
R8299 XRX.XCAP.O_QBBUF.n7 XRX.XCAP.O_QBBUF.t6 113.629
R8300 XRX.XCAP.O_QBBUF.n5 XRX.XCAP.O_QBBUF.t4 109.174
R8301 XRX.XCAP.O_QBBUF.n6 XRX.XCAP.O_QBBUF.t5 109.174
R8302 XRX.XCAP.O_QBBUF.n1 XRX.XCAP.O_QBBUF.t8 109.174
R8303 XRX.XCAP.O_QBBUF.n2 XRX.XCAP.O_QBBUF.t9 109.174
R8304 XRX.XCAP.O_QBBUF.n8 XRX.XCAP.O_QBBUF.n5 18.6022
R8305 XRX.XCAP.O_QBBUF.n9 XRX.XCAP.O_QBBUF.n4 17.394
R8306 XRX.XCAP.O_QBBUF.n6 XRX.XCAP.O_QBBUF.n5 11.6805
R8307 XRX.XCAP.O_QBBUF.n2 XRX.XCAP.O_QBBUF.n1 11.6805
R8308 XRX.XCAP.O_QBBUF.n12 XRX.XCAP.O_QBBUF.n10 10.4648
R8309 XRX.XCAP.O_QBBUF.n9 XRX.XCAP.O_QBBUF.n8 9.21572
R8310 XRX.XCAP.O_QBBUF.n13 XRX.XCAP.O_QBBUF.n9 7.16137
R8311 XRX.XCAP.O_QBBUF.n4 XRX.XCAP.O_QBBUF.n0 7.10487
R8312 XRX.XCAP.O_QBBUF.n4 XRX.XCAP.O_QBBUF.n3 7.10487
R8313 XRX.XCAP.O_QBBUF.n8 XRX.XCAP.O_QBBUF.n7 7.05405
R8314 XRX.XCAP.O_QBBUF.n11 XRX.XCAP.O_QBBUF.t3 6.07983
R8315 XRX.XCAP.O_QBBUF.n11 XRX.XCAP.O_QBBUF.t2 5.89036
R8316 XRX.XCAP.O_QBBUF.n10 XRX.XCAP.O_QBBUF.t1 5.73764
R8317 XRX.XCAP.O_QBBUF.n10 XRX.XCAP.O_QBBUF.t0 5.54817
R8318 XRX.XCAP.O_QBBUF.n13 XRX.XCAP.O_QBBUF.n12 5.43963
R8319 XRX.XCAP.O_QBBUF.n12 XRX.XCAP.O_QBBUF.n11 4.59524
R8320 XRX.XCAP.O_QBBUF.n7 XRX.XCAP.O_QBBUF.n6 4.4296
R8321 XRX.XCAP.O_QBBUF.n1 XRX.XCAP.O_QBBUF.n0 4.42851
R8322 XRX.XCAP.O_QBBUF.n3 XRX.XCAP.O_QBBUF.n2 4.42851
R8323 XRX.XCAP.O_QBBUF XRX.XCAP.O_QBBUF.n13 0.0396304
R8324 XRX.XCAP.O_QBUF.n0 XRX.XCAP.O_QBUF.t7 113.632
R8325 XRX.XCAP.O_QBUF.n3 XRX.XCAP.O_QBUF.t10 113.632
R8326 XRX.XCAP.O_QBUF.n7 XRX.XCAP.O_QBUF.t6 113.629
R8327 XRX.XCAP.O_QBUF.n5 XRX.XCAP.O_QBUF.t4 109.174
R8328 XRX.XCAP.O_QBUF.n6 XRX.XCAP.O_QBUF.t5 109.174
R8329 XRX.XCAP.O_QBUF.n1 XRX.XCAP.O_QBUF.t8 109.174
R8330 XRX.XCAP.O_QBUF.n2 XRX.XCAP.O_QBUF.t9 109.174
R8331 XRX.XCAP.O_QBUF.n8 XRX.XCAP.O_QBUF.n5 18.6022
R8332 XRX.XCAP.O_QBUF.n9 XRX.XCAP.O_QBUF.n4 17.1201
R8333 XRX.XCAP.O_QBUF.n6 XRX.XCAP.O_QBUF.n5 11.6805
R8334 XRX.XCAP.O_QBUF.n2 XRX.XCAP.O_QBUF.n1 11.6805
R8335 XRX.XCAP.O_QBUF.n12 XRX.XCAP.O_QBUF.n10 10.4648
R8336 XRX.XCAP.O_QBUF.n9 XRX.XCAP.O_QBUF.n8 9.48963
R8337 XRX.XCAP.O_QBUF.n13 XRX.XCAP.O_QBUF.n9 7.16137
R8338 XRX.XCAP.O_QBUF.n4 XRX.XCAP.O_QBUF.n0 7.10487
R8339 XRX.XCAP.O_QBUF.n4 XRX.XCAP.O_QBUF.n3 7.10487
R8340 XRX.XCAP.O_QBUF.n8 XRX.XCAP.O_QBUF.n7 7.05405
R8341 XRX.XCAP.O_QBUF.n11 XRX.XCAP.O_QBUF.t1 6.07983
R8342 XRX.XCAP.O_QBUF.n11 XRX.XCAP.O_QBUF.t2 5.89036
R8343 XRX.XCAP.O_QBUF.n10 XRX.XCAP.O_QBUF.t0 5.73764
R8344 XRX.XCAP.O_QBUF.n10 XRX.XCAP.O_QBUF.t3 5.54817
R8345 XRX.XCAP.O_QBUF.n13 XRX.XCAP.O_QBUF.n12 5.16572
R8346 XRX.XCAP.O_QBUF.n12 XRX.XCAP.O_QBUF.n11 4.59524
R8347 XRX.XCAP.O_QBUF.n7 XRX.XCAP.O_QBUF.n6 4.4296
R8348 XRX.XCAP.O_QBUF.n1 XRX.XCAP.O_QBUF.n0 4.42851
R8349 XRX.XCAP.O_QBUF.n3 XRX.XCAP.O_QBUF.n2 4.42851
R8350 XRX.XCAP.O_QBUF XRX.XCAP.O_QBUF.n13 0.0396304
R8351 XRX.XCAP.E_QBUF.n3 XRX.XCAP.E_QBUF.t7 113.632
R8352 XRX.XCAP.E_QBUF.n6 XRX.XCAP.E_QBUF.t10 113.632
R8353 XRX.XCAP.E_QBUF.n10 XRX.XCAP.E_QBUF.t6 113.629
R8354 XRX.XCAP.E_QBUF.n8 XRX.XCAP.E_QBUF.t4 109.174
R8355 XRX.XCAP.E_QBUF.n9 XRX.XCAP.E_QBUF.t5 109.174
R8356 XRX.XCAP.E_QBUF.n4 XRX.XCAP.E_QBUF.t8 109.174
R8357 XRX.XCAP.E_QBUF.n5 XRX.XCAP.E_QBUF.t9 109.174
R8358 XRX.XCAP.E_QBUF.n11 XRX.XCAP.E_QBUF.n8 18.6022
R8359 XRX.XCAP.E_QBUF.n12 XRX.XCAP.E_QBUF.n7 17.6092
R8360 XRX.XCAP.E_QBUF.n9 XRX.XCAP.E_QBUF.n8 11.6805
R8361 XRX.XCAP.E_QBUF.n5 XRX.XCAP.E_QBUF.n4 11.6805
R8362 XRX.XCAP.E_QBUF.n2 XRX.XCAP.E_QBUF.n0 10.4648
R8363 XRX.XCAP.E_QBUF.n12 XRX.XCAP.E_QBUF.n11 9.0005
R8364 XRX.XCAP.E_QBUF.n13 XRX.XCAP.E_QBUF.n2 7.74833
R8365 XRX.XCAP.E_QBUF.n7 XRX.XCAP.E_QBUF.n3 7.10487
R8366 XRX.XCAP.E_QBUF.n7 XRX.XCAP.E_QBUF.n6 7.10487
R8367 XRX.XCAP.E_QBUF.n11 XRX.XCAP.E_QBUF.n10 7.05405
R8368 XRX.XCAP.E_QBUF.n1 XRX.XCAP.E_QBUF.t2 6.07983
R8369 XRX.XCAP.E_QBUF.n1 XRX.XCAP.E_QBUF.t3 5.89036
R8370 XRX.XCAP.E_QBUF.n0 XRX.XCAP.E_QBUF.t0 5.73764
R8371 XRX.XCAP.E_QBUF.n0 XRX.XCAP.E_QBUF.t1 5.54817
R8372 XRX.XCAP.E_QBUF.n2 XRX.XCAP.E_QBUF.n1 4.59524
R8373 XRX.XCAP.E_QBUF.n13 XRX.XCAP.E_QBUF.n12 4.5592
R8374 XRX.XCAP.E_QBUF.n10 XRX.XCAP.E_QBUF.n9 4.4296
R8375 XRX.XCAP.E_QBUF.n4 XRX.XCAP.E_QBUF.n3 4.42851
R8376 XRX.XCAP.E_QBUF.n6 XRX.XCAP.E_QBUF.n5 4.42851
R8377 XRX.XCAP.E_QBUF XRX.XCAP.E_QBUF.n13 0.0396304
R8378 XRX.XCAP.E_QBBUF.n3 XRX.XCAP.E_QBBUF.t7 113.632
R8379 XRX.XCAP.E_QBBUF.n6 XRX.XCAP.E_QBBUF.t10 113.632
R8380 XRX.XCAP.E_QBBUF.n10 XRX.XCAP.E_QBBUF.t6 113.629
R8381 XRX.XCAP.E_QBBUF.n8 XRX.XCAP.E_QBBUF.t4 109.174
R8382 XRX.XCAP.E_QBBUF.n9 XRX.XCAP.E_QBBUF.t5 109.174
R8383 XRX.XCAP.E_QBBUF.n4 XRX.XCAP.E_QBBUF.t8 109.174
R8384 XRX.XCAP.E_QBBUF.n5 XRX.XCAP.E_QBBUF.t9 109.174
R8385 XRX.XCAP.E_QBBUF.n11 XRX.XCAP.E_QBBUF.n8 18.6022
R8386 XRX.XCAP.E_QBBUF.n12 XRX.XCAP.E_QBBUF.n7 17.6092
R8387 XRX.XCAP.E_QBBUF.n9 XRX.XCAP.E_QBBUF.n8 11.6805
R8388 XRX.XCAP.E_QBBUF.n5 XRX.XCAP.E_QBBUF.n4 11.6805
R8389 XRX.XCAP.E_QBBUF.n2 XRX.XCAP.E_QBBUF.n0 10.4648
R8390 XRX.XCAP.E_QBBUF.n12 XRX.XCAP.E_QBBUF.n11 9.0005
R8391 XRX.XCAP.E_QBBUF.n13 XRX.XCAP.E_QBBUF.n2 8.02224
R8392 XRX.XCAP.E_QBBUF.n7 XRX.XCAP.E_QBBUF.n3 7.10487
R8393 XRX.XCAP.E_QBBUF.n7 XRX.XCAP.E_QBBUF.n6 7.10487
R8394 XRX.XCAP.E_QBBUF.n11 XRX.XCAP.E_QBBUF.n10 7.05405
R8395 XRX.XCAP.E_QBBUF.n1 XRX.XCAP.E_QBBUF.t3 6.07983
R8396 XRX.XCAP.E_QBBUF.n1 XRX.XCAP.E_QBBUF.t2 5.89036
R8397 XRX.XCAP.E_QBBUF.n0 XRX.XCAP.E_QBBUF.t1 5.73764
R8398 XRX.XCAP.E_QBBUF.n0 XRX.XCAP.E_QBBUF.t0 5.54817
R8399 XRX.XCAP.E_QBBUF.n13 XRX.XCAP.E_QBBUF.n12 4.83311
R8400 XRX.XCAP.E_QBBUF.n2 XRX.XCAP.E_QBBUF.n1 4.59524
R8401 XRX.XCAP.E_QBBUF.n10 XRX.XCAP.E_QBBUF.n9 4.4296
R8402 XRX.XCAP.E_QBBUF.n4 XRX.XCAP.E_QBBUF.n3 4.42851
R8403 XRX.XCAP.E_QBBUF.n6 XRX.XCAP.E_QBBUF.n5 4.42851
R8404 XRX.XCAP.E_QBBUF XRX.XCAP.E_QBBUF.n13 0.0396304
R8405 XRX.XCAP.O_QBI.n14 XRX.XCAP.O_QBI.t19 113.632
R8406 XRX.XCAP.O_QBI.n4 XRX.XCAP.O_QBI.t12 113.618
R8407 XRX.XCAP.O_QBI.n4 XRX.XCAP.O_QBI.t13 113.618
R8408 XRX.XCAP.O_QBI.n2 XRX.XCAP.O_QBI.t16 113.618
R8409 XRX.XCAP.O_QBI.n2 XRX.XCAP.O_QBI.t17 113.618
R8410 XRX.XCAP.O_QBI.n14 XRX.XCAP.O_QBI.t18 113.603
R8411 XRX.XCAP.O_QBI.n15 XRX.XCAP.O_QBI.t15 61.4885
R8412 XRX.XCAP.O_QBI.n15 XRX.XCAP.O_QBI.t14 61.4598
R8413 XRX.XCAP.O_QBI.n16 XRX.XCAP.O_QBI.n14 21.4318
R8414 XRX.XCAP.O_QBI.n5 XRX.XCAP.O_QBI.n4 17.8026
R8415 XRX.XCAP.O_QBI.n16 XRX.XCAP.O_QBI.n15 16.3449
R8416 XRX.XCAP.O_QBI.n3 XRX.XCAP.O_QBI.n2 16.0613
R8417 XRX.XCAP.O_QBI.n3 XRX.XCAP.O_QBI.n1 14.0679
R8418 XRX.XCAP.O_QBI.n12 XRX.XCAP.O_QBI.n6 9.19615
R8419 XRX.XCAP.O_QBI.n11 XRX.XCAP.O_QBI.n9 7.43528
R8420 XRX.XCAP.O_QBI.n13 XRX.XCAP.O_QBI.n5 7.00485
R8421 XRX.XCAP.O_QBI.n8 XRX.XCAP.O_QBI.t7 5.7796
R8422 XRX.XCAP.O_QBI.n10 XRX.XCAP.O_QBI.t3 5.7796
R8423 XRX.XCAP.O_QBI.n6 XRX.XCAP.O_QBI.t1 5.73764
R8424 XRX.XCAP.O_QBI.n1 XRX.XCAP.O_QBI.t6 5.73764
R8425 XRX.XCAP.O_QBI.n1 XRX.XCAP.O_QBI.t4 5.73764
R8426 XRX.XCAP.O_QBI.n9 XRX.XCAP.O_QBI.t5 5.68486
R8427 XRX.XCAP.O_QBI.n10 XRX.XCAP.O_QBI.t2 5.59012
R8428 XRX.XCAP.O_QBI.n6 XRX.XCAP.O_QBI.t0 5.54817
R8429 XRX.XCAP.O_QBI.n17 XRX.XCAP.O_QBI.n16 5.49833
R8430 XRX.XCAP.O_QBI.n8 XRX.XCAP.O_QBI.n7 5.38537
R8431 XRX.XCAP.O_QBI.n1 XRX.XCAP.O_QBI.n0 5.32067
R8432 XRX.XCAP.O_QBI.n11 XRX.XCAP.O_QBI.n10 4.5005
R8433 XRX.XCAP.O_QBI.n13 XRX.XCAP.O_QBI.n12 4.5005
R8434 XRX.XCAP.O_QBI.n5 XRX.XCAP.O_QBI.n3 3.1505
R8435 XRX.XCAP.O_QBI.n17 XRX.XCAP.O_QBI.n13 2.89615
R8436 XRX.XCAP.O_QBI.n0 XRX.XCAP.O_QBI.t9 0.228
R8437 XRX.XCAP.O_QBI.n0 XRX.XCAP.O_QBI.t8 0.228
R8438 XRX.XCAP.O_QBI.n7 XRX.XCAP.O_QBI.t11 0.20525
R8439 XRX.XCAP.O_QBI.n7 XRX.XCAP.O_QBI.t10 0.20525
R8440 XRX.XCAP.O_QBI.n12 XRX.XCAP.O_QBI.n11 0.196152
R8441 XRX.XCAP.O_QBI.n9 XRX.XCAP.O_QBI.n8 0.0952368
R8442 XRX.XCAP.O_QBI XRX.XCAP.O_QBI.n17 0.0396304
R8443 XRX.XCAP.O_PRST_TAIL.n10 XRX.XCAP.O_PRST_TAIL.n2 19.1064
R8444 XRX.XCAP.O_PRST_TAIL.n10 XRX.XCAP.O_PRST_TAIL.n9 17.603
R8445 XRX.XCAP.O_PRST_TAIL.n4 XRX.XCAP.O_PRST_TAIL.t7 5.73764
R8446 XRX.XCAP.O_PRST_TAIL.n9 XRX.XCAP.O_PRST_TAIL.t0 5.54817
R8447 XRX.XCAP.O_PRST_TAIL.n2 XRX.XCAP.O_PRST_TAIL.n0 5.51014
R8448 XRX.XCAP.O_PRST_TAIL.n2 XRX.XCAP.O_PRST_TAIL.n1 5.32067
R8449 XRX.XCAP.O_PRST_TAIL.n4 XRX.XCAP.O_PRST_TAIL.n3 5.32067
R8450 XRX.XCAP.O_PRST_TAIL.n6 XRX.XCAP.O_PRST_TAIL.n5 5.32067
R8451 XRX.XCAP.O_PRST_TAIL.n8 XRX.XCAP.O_PRST_TAIL.n7 5.32067
R8452 XRX.XCAP.O_PRST_TAIL.n0 XRX.XCAP.O_PRST_TAIL.t10 0.228
R8453 XRX.XCAP.O_PRST_TAIL.n0 XRX.XCAP.O_PRST_TAIL.t9 0.228
R8454 XRX.XCAP.O_PRST_TAIL.n1 XRX.XCAP.O_PRST_TAIL.t8 0.228
R8455 XRX.XCAP.O_PRST_TAIL.n1 XRX.XCAP.O_PRST_TAIL.t11 0.228
R8456 XRX.XCAP.O_PRST_TAIL.n3 XRX.XCAP.O_PRST_TAIL.t5 0.228
R8457 XRX.XCAP.O_PRST_TAIL.n3 XRX.XCAP.O_PRST_TAIL.t6 0.228
R8458 XRX.XCAP.O_PRST_TAIL.n5 XRX.XCAP.O_PRST_TAIL.t3 0.228
R8459 XRX.XCAP.O_PRST_TAIL.n5 XRX.XCAP.O_PRST_TAIL.t4 0.228
R8460 XRX.XCAP.O_PRST_TAIL.n7 XRX.XCAP.O_PRST_TAIL.t1 0.228
R8461 XRX.XCAP.O_PRST_TAIL.n7 XRX.XCAP.O_PRST_TAIL.t2 0.228
R8462 XRX.XCAP.O_PRST_TAIL.n9 XRX.XCAP.O_PRST_TAIL.n8 0.189974
R8463 XRX.XCAP.O_PRST_TAIL.n8 XRX.XCAP.O_PRST_TAIL.n6 0.189974
R8464 XRX.XCAP.O_PRST_TAIL.n6 XRX.XCAP.O_PRST_TAIL.n4 0.189974
R8465 XRX.XCAP.O_PRST_TAIL XRX.XCAP.O_PRST_TAIL.n10 0.0396304
R8466 XRX.XCAP.E_PRST_TAIL.n10 XRX.XCAP.E_PRST_TAIL.n6 24.2305
R8467 XRX.XCAP.E_PRST_TAIL.n10 XRX.XCAP.E_PRST_TAIL.n9 17.0881
R8468 XRX.XCAP.E_PRST_TAIL.n1 XRX.XCAP.E_PRST_TAIL.t4 5.73764
R8469 XRX.XCAP.E_PRST_TAIL.n6 XRX.XCAP.E_PRST_TAIL.t11 5.54817
R8470 XRX.XCAP.E_PRST_TAIL.n9 XRX.XCAP.E_PRST_TAIL.n7 5.51014
R8471 XRX.XCAP.E_PRST_TAIL.n5 XRX.XCAP.E_PRST_TAIL.n4 5.32067
R8472 XRX.XCAP.E_PRST_TAIL.n9 XRX.XCAP.E_PRST_TAIL.n8 5.32067
R8473 XRX.XCAP.E_PRST_TAIL.n3 XRX.XCAP.E_PRST_TAIL.n2 5.32067
R8474 XRX.XCAP.E_PRST_TAIL.n1 XRX.XCAP.E_PRST_TAIL.n0 5.32067
R8475 XRX.XCAP.E_PRST_TAIL.n4 XRX.XCAP.E_PRST_TAIL.t9 0.228
R8476 XRX.XCAP.E_PRST_TAIL.n4 XRX.XCAP.E_PRST_TAIL.t10 0.228
R8477 XRX.XCAP.E_PRST_TAIL.n7 XRX.XCAP.E_PRST_TAIL.t1 0.228
R8478 XRX.XCAP.E_PRST_TAIL.n7 XRX.XCAP.E_PRST_TAIL.t0 0.228
R8479 XRX.XCAP.E_PRST_TAIL.n8 XRX.XCAP.E_PRST_TAIL.t3 0.228
R8480 XRX.XCAP.E_PRST_TAIL.n8 XRX.XCAP.E_PRST_TAIL.t2 0.228
R8481 XRX.XCAP.E_PRST_TAIL.n2 XRX.XCAP.E_PRST_TAIL.t7 0.228
R8482 XRX.XCAP.E_PRST_TAIL.n2 XRX.XCAP.E_PRST_TAIL.t8 0.228
R8483 XRX.XCAP.E_PRST_TAIL.n0 XRX.XCAP.E_PRST_TAIL.t5 0.228
R8484 XRX.XCAP.E_PRST_TAIL.n0 XRX.XCAP.E_PRST_TAIL.t6 0.228
R8485 XRX.XCAP.E_PRST_TAIL.n3 XRX.XCAP.E_PRST_TAIL.n1 0.189974
R8486 XRX.XCAP.E_PRST_TAIL.n5 XRX.XCAP.E_PRST_TAIL.n3 0.189974
R8487 XRX.XCAP.E_PRST_TAIL.n6 XRX.XCAP.E_PRST_TAIL.n5 0.189974
R8488 XRX.XCAP.E_PRST_TAIL XRX.XCAP.E_PRST_TAIL.n10 0.0396304
R8489 XRX.XCAP.E_QBI.n0 XRX.XCAP.E_QBI.t19 113.632
R8490 XRX.XCAP.E_QBI.n15 XRX.XCAP.E_QBI.t12 113.618
R8491 XRX.XCAP.E_QBI.n15 XRX.XCAP.E_QBI.t13 113.618
R8492 XRX.XCAP.E_QBI.n13 XRX.XCAP.E_QBI.t16 113.618
R8493 XRX.XCAP.E_QBI.n13 XRX.XCAP.E_QBI.t17 113.618
R8494 XRX.XCAP.E_QBI.n0 XRX.XCAP.E_QBI.t18 113.603
R8495 XRX.XCAP.E_QBI.n1 XRX.XCAP.E_QBI.t15 61.4885
R8496 XRX.XCAP.E_QBI.n1 XRX.XCAP.E_QBI.t14 61.4598
R8497 XRX.XCAP.E_QBI.n2 XRX.XCAP.E_QBI.n0 21.4318
R8498 XRX.XCAP.E_QBI.n16 XRX.XCAP.E_QBI.n15 17.2548
R8499 XRX.XCAP.E_QBI.n2 XRX.XCAP.E_QBI.n1 16.3449
R8500 XRX.XCAP.E_QBI.n14 XRX.XCAP.E_QBI.n13 16.0613
R8501 XRX.XCAP.E_QBI.n14 XRX.XCAP.E_QBI.n12 14.0679
R8502 XRX.XCAP.E_QBI.n10 XRX.XCAP.E_QBI.n2 10.194
R8503 XRX.XCAP.E_QBI.n5 XRX.XCAP.E_QBI.n3 9.3918
R8504 XRX.XCAP.E_QBI.n9 XRX.XCAP.E_QBI.n8 7.08311
R8505 XRX.XCAP.E_QBI.n7 XRX.XCAP.E_QBI.t2 5.7796
R8506 XRX.XCAP.E_QBI.n4 XRX.XCAP.E_QBI.t11 5.7796
R8507 XRX.XCAP.E_QBI.n3 XRX.XCAP.E_QBI.t9 5.73764
R8508 XRX.XCAP.E_QBI.n12 XRX.XCAP.E_QBI.t0 5.73764
R8509 XRX.XCAP.E_QBI.n12 XRX.XCAP.E_QBI.t7 5.73764
R8510 XRX.XCAP.E_QBI.n8 XRX.XCAP.E_QBI.t5 5.68486
R8511 XRX.XCAP.E_QBI.n4 XRX.XCAP.E_QBI.t10 5.59012
R8512 XRX.XCAP.E_QBI.n3 XRX.XCAP.E_QBI.t8 5.54817
R8513 XRX.XCAP.E_QBI.n7 XRX.XCAP.E_QBI.n6 5.38537
R8514 XRX.XCAP.E_QBI.n12 XRX.XCAP.E_QBI.n11 5.32067
R8515 XRX.XCAP.E_QBI.n5 XRX.XCAP.E_QBI.n4 4.5005
R8516 XRX.XCAP.E_QBI.n10 XRX.XCAP.E_QBI.n9 4.5005
R8517 XRX.XCAP.E_QBI.n17 XRX.XCAP.E_QBI.n16 4.5005
R8518 XRX.XCAP.E_QBI.n16 XRX.XCAP.E_QBI.n14 3.69833
R8519 XRX.XCAP.E_QBI.n17 XRX.XCAP.E_QBI.n10 2.1918
R8520 XRX.XCAP.E_QBI.n9 XRX.XCAP.E_QBI.n5 0.352674
R8521 XRX.XCAP.E_QBI.n11 XRX.XCAP.E_QBI.t6 0.228
R8522 XRX.XCAP.E_QBI.n11 XRX.XCAP.E_QBI.t1 0.228
R8523 XRX.XCAP.E_QBI.n6 XRX.XCAP.E_QBI.t4 0.20525
R8524 XRX.XCAP.E_QBI.n6 XRX.XCAP.E_QBI.t3 0.20525
R8525 XRX.XCAP.E_QBI.n8 XRX.XCAP.E_QBI.n7 0.0952368
R8526 XRX.XCAP.E_QBI XRX.XCAP.E_QBI.n17 0.0396304
R8527 XRX.XCAP.ODD_D_BUF.n19 XRX.XCAP.ODD_D_BUF.t12 113.632
R8528 XRX.XCAP.ODD_D_BUF.n12 XRX.XCAP.ODD_D_BUF.t19 113.632
R8529 XRX.XCAP.ODD_D_BUF.n22 XRX.XCAP.ODD_D_BUF.t15 109.174
R8530 XRX.XCAP.ODD_D_BUF.n21 XRX.XCAP.ODD_D_BUF.t14 109.174
R8531 XRX.XCAP.ODD_D_BUF.n20 XRX.XCAP.ODD_D_BUF.t13 109.174
R8532 XRX.XCAP.ODD_D_BUF.n15 XRX.XCAP.ODD_D_BUF.t16 109.174
R8533 XRX.XCAP.ODD_D_BUF.n14 XRX.XCAP.ODD_D_BUF.t17 109.174
R8534 XRX.XCAP.ODD_D_BUF.n13 XRX.XCAP.ODD_D_BUF.t18 109.174
R8535 XRX.XCAP.ODD_D_BUF.n24 XRX.XCAP.ODD_D_BUF.n23 23.4289
R8536 XRX.XCAP.ODD_D_BUF.n17 XRX.XCAP.ODD_D_BUF.n16 20.1159
R8537 XRX.XCAP.ODD_D_BUF.n23 XRX.XCAP.ODD_D_BUF.n22 18.4942
R8538 XRX.XCAP.ODD_D_BUF.n21 XRX.XCAP.ODD_D_BUF.n18 18.4942
R8539 XRX.XCAP.ODD_D_BUF.n16 XRX.XCAP.ODD_D_BUF.n15 18.4942
R8540 XRX.XCAP.ODD_D_BUF.n14 XRX.XCAP.ODD_D_BUF.n11 18.4942
R8541 XRX.XCAP.ODD_D_BUF.n22 XRX.XCAP.ODD_D_BUF.n21 11.6805
R8542 XRX.XCAP.ODD_D_BUF.n21 XRX.XCAP.ODD_D_BUF.n20 11.6805
R8543 XRX.XCAP.ODD_D_BUF.n15 XRX.XCAP.ODD_D_BUF.n14 11.6805
R8544 XRX.XCAP.ODD_D_BUF.n14 XRX.XCAP.ODD_D_BUF.n13 11.6805
R8545 XRX.XCAP.ODD_D_BUF.n10 XRX.XCAP.ODD_D_BUF.n2 10.3701
R8546 XRX.XCAP.ODD_D_BUF.n17 XRX.XCAP.ODD_D_BUF.n10 8.45267
R8547 XRX.XCAP.ODD_D_BUF.n19 XRX.XCAP.ODD_D_BUF.n18 7.17687
R8548 XRX.XCAP.ODD_D_BUF.n12 XRX.XCAP.ODD_D_BUF.n11 7.17687
R8549 XRX.XCAP.ODD_D_BUF.n1 XRX.XCAP.ODD_D_BUF.t11 5.7796
R8550 XRX.XCAP.ODD_D_BUF.n4 XRX.XCAP.ODD_D_BUF.t7 5.73764
R8551 XRX.XCAP.ODD_D_BUF.n8 XRX.XCAP.ODD_D_BUF.t0 5.73764
R8552 XRX.XCAP.ODD_D_BUF.n2 XRX.XCAP.ODD_D_BUF.t8 5.68486
R8553 XRX.XCAP.ODD_D_BUF.n1 XRX.XCAP.ODD_D_BUF.n0 5.38537
R8554 XRX.XCAP.ODD_D_BUF.n4 XRX.XCAP.ODD_D_BUF.n3 5.32067
R8555 XRX.XCAP.ODD_D_BUF.n6 XRX.XCAP.ODD_D_BUF.n5 5.32067
R8556 XRX.XCAP.ODD_D_BUF.n8 XRX.XCAP.ODD_D_BUF.n7 5.32067
R8557 XRX.XCAP.ODD_D_BUF.n10 XRX.XCAP.ODD_D_BUF.n9 4.5005
R8558 XRX.XCAP.ODD_D_BUF.n20 XRX.XCAP.ODD_D_BUF.n19 4.42851
R8559 XRX.XCAP.ODD_D_BUF.n13 XRX.XCAP.ODD_D_BUF.n12 4.42851
R8560 XRX.XCAP.ODD_D_BUF.n24 XRX.XCAP.ODD_D_BUF.n17 3.75702
R8561 XRX.XCAP.ODD_D_BUF.n3 XRX.XCAP.ODD_D_BUF.t5 0.228
R8562 XRX.XCAP.ODD_D_BUF.n3 XRX.XCAP.ODD_D_BUF.t6 0.228
R8563 XRX.XCAP.ODD_D_BUF.n5 XRX.XCAP.ODD_D_BUF.t3 0.228
R8564 XRX.XCAP.ODD_D_BUF.n5 XRX.XCAP.ODD_D_BUF.t4 0.228
R8565 XRX.XCAP.ODD_D_BUF.n7 XRX.XCAP.ODD_D_BUF.t1 0.228
R8566 XRX.XCAP.ODD_D_BUF.n7 XRX.XCAP.ODD_D_BUF.t2 0.228
R8567 XRX.XCAP.ODD_D_BUF.n0 XRX.XCAP.ODD_D_BUF.t9 0.20525
R8568 XRX.XCAP.ODD_D_BUF.n0 XRX.XCAP.ODD_D_BUF.t10 0.20525
R8569 XRX.XCAP.ODD_D_BUF.n6 XRX.XCAP.ODD_D_BUF.n4 0.189974
R8570 XRX.XCAP.ODD_D_BUF.n23 XRX.XCAP.ODD_D_BUF.n18 0.1205
R8571 XRX.XCAP.ODD_D_BUF.n16 XRX.XCAP.ODD_D_BUF.n11 0.1205
R8572 XRX.XCAP.ODD_D_BUF.n9 XRX.XCAP.ODD_D_BUF.n8 0.0952368
R8573 XRX.XCAP.ODD_D_BUF.n9 XRX.XCAP.ODD_D_BUF.n6 0.0952368
R8574 XRX.XCAP.ODD_D_BUF.n2 XRX.XCAP.ODD_D_BUF.n1 0.0952368
R8575 XRX.XCAP.ODD_D_BUF XRX.XCAP.ODD_D_BUF.n24 0.0396304
R8576 XRX.XCAP.EVEN_D_BUF.n1 XRX.XCAP.EVEN_D_BUF.t12 113.632
R8577 XRX.XCAP.EVEN_D_BUF.n7 XRX.XCAP.EVEN_D_BUF.t16 113.632
R8578 XRX.XCAP.EVEN_D_BUF.n4 XRX.XCAP.EVEN_D_BUF.t15 109.174
R8579 XRX.XCAP.EVEN_D_BUF.n3 XRX.XCAP.EVEN_D_BUF.t14 109.174
R8580 XRX.XCAP.EVEN_D_BUF.n2 XRX.XCAP.EVEN_D_BUF.t13 109.174
R8581 XRX.XCAP.EVEN_D_BUF.n8 XRX.XCAP.EVEN_D_BUF.t17 109.174
R8582 XRX.XCAP.EVEN_D_BUF.n9 XRX.XCAP.EVEN_D_BUF.t18 109.174
R8583 XRX.XCAP.EVEN_D_BUF.n10 XRX.XCAP.EVEN_D_BUF.t19 109.174
R8584 XRX.XCAP.EVEN_D_BUF.n12 XRX.XCAP.EVEN_D_BUF.n5 25.855
R8585 XRX.XCAP.EVEN_D_BUF.n12 XRX.XCAP.EVEN_D_BUF.n11 20.5437
R8586 XRX.XCAP.EVEN_D_BUF.n5 XRX.XCAP.EVEN_D_BUF.n4 18.4942
R8587 XRX.XCAP.EVEN_D_BUF.n3 XRX.XCAP.EVEN_D_BUF.n0 18.4942
R8588 XRX.XCAP.EVEN_D_BUF.n9 XRX.XCAP.EVEN_D_BUF.n6 18.4942
R8589 XRX.XCAP.EVEN_D_BUF.n11 XRX.XCAP.EVEN_D_BUF.n10 18.4942
R8590 XRX.XCAP.EVEN_D_BUF.n4 XRX.XCAP.EVEN_D_BUF.n3 11.6805
R8591 XRX.XCAP.EVEN_D_BUF.n3 XRX.XCAP.EVEN_D_BUF.n2 11.6805
R8592 XRX.XCAP.EVEN_D_BUF.n9 XRX.XCAP.EVEN_D_BUF.n8 11.6805
R8593 XRX.XCAP.EVEN_D_BUF.n10 XRX.XCAP.EVEN_D_BUF.n9 11.6805
R8594 XRX.XCAP.EVEN_D_BUF.n23 XRX.XCAP.EVEN_D_BUF.n22 10.3309
R8595 XRX.XCAP.EVEN_D_BUF.n1 XRX.XCAP.EVEN_D_BUF.n0 7.17687
R8596 XRX.XCAP.EVEN_D_BUF.n7 XRX.XCAP.EVEN_D_BUF.n6 7.17687
R8597 XRX.XCAP.EVEN_D_BUF.n21 XRX.XCAP.EVEN_D_BUF.t11 5.7796
R8598 XRX.XCAP.EVEN_D_BUF.n14 XRX.XCAP.EVEN_D_BUF.t7 5.73764
R8599 XRX.XCAP.EVEN_D_BUF.n18 XRX.XCAP.EVEN_D_BUF.t0 5.73764
R8600 XRX.XCAP.EVEN_D_BUF.n22 XRX.XCAP.EVEN_D_BUF.t8 5.68486
R8601 XRX.XCAP.EVEN_D_BUF.n21 XRX.XCAP.EVEN_D_BUF.n20 5.38537
R8602 XRX.XCAP.EVEN_D_BUF.n14 XRX.XCAP.EVEN_D_BUF.n13 5.32067
R8603 XRX.XCAP.EVEN_D_BUF.n16 XRX.XCAP.EVEN_D_BUF.n15 5.32067
R8604 XRX.XCAP.EVEN_D_BUF.n18 XRX.XCAP.EVEN_D_BUF.n17 5.32067
R8605 XRX.XCAP.EVEN_D_BUF.n23 XRX.XCAP.EVEN_D_BUF.n19 4.53963
R8606 XRX.XCAP.EVEN_D_BUF.n24 XRX.XCAP.EVEN_D_BUF.n23 4.5005
R8607 XRX.XCAP.EVEN_D_BUF.n2 XRX.XCAP.EVEN_D_BUF.n1 4.42851
R8608 XRX.XCAP.EVEN_D_BUF.n8 XRX.XCAP.EVEN_D_BUF.n7 4.42851
R8609 XRX.XCAP.EVEN_D_BUF.n24 XRX.XCAP.EVEN_D_BUF.n12 3.91354
R8610 XRX.XCAP.EVEN_D_BUF.n13 XRX.XCAP.EVEN_D_BUF.t5 0.228
R8611 XRX.XCAP.EVEN_D_BUF.n13 XRX.XCAP.EVEN_D_BUF.t6 0.228
R8612 XRX.XCAP.EVEN_D_BUF.n15 XRX.XCAP.EVEN_D_BUF.t3 0.228
R8613 XRX.XCAP.EVEN_D_BUF.n15 XRX.XCAP.EVEN_D_BUF.t4 0.228
R8614 XRX.XCAP.EVEN_D_BUF.n17 XRX.XCAP.EVEN_D_BUF.t1 0.228
R8615 XRX.XCAP.EVEN_D_BUF.n17 XRX.XCAP.EVEN_D_BUF.t2 0.228
R8616 XRX.XCAP.EVEN_D_BUF.n20 XRX.XCAP.EVEN_D_BUF.t9 0.20525
R8617 XRX.XCAP.EVEN_D_BUF.n20 XRX.XCAP.EVEN_D_BUF.t10 0.20525
R8618 XRX.XCAP.EVEN_D_BUF.n16 XRX.XCAP.EVEN_D_BUF.n14 0.189974
R8619 XRX.XCAP.EVEN_D_BUF.n5 XRX.XCAP.EVEN_D_BUF.n0 0.1205
R8620 XRX.XCAP.EVEN_D_BUF.n11 XRX.XCAP.EVEN_D_BUF.n6 0.1205
R8621 XRX.XCAP.EVEN_D_BUF.n19 XRX.XCAP.EVEN_D_BUF.n18 0.0952368
R8622 XRX.XCAP.EVEN_D_BUF.n19 XRX.XCAP.EVEN_D_BUF.n16 0.0952368
R8623 XRX.XCAP.EVEN_D_BUF.n22 XRX.XCAP.EVEN_D_BUF.n21 0.0952368
R8624 XRX.XCAP.EVEN_D_BUF XRX.XCAP.EVEN_D_BUF.n24 0.0396304
C0 VDD TERM_EN5_N 1.84084f
C1 XRX.XFRONT.XFE_E.NREGEN SAMP_E_P 0.01317f
C2 XRX.XCAP.O_QBI XRX.XCAP.O_PSET_TAIL 0.30508f
C3 XRX.XCAP.ODD_D_BUF XRX.XCAP.O_RST_TAIL 0.70292f
C4 XRX.XCAP.E_QBI XRX.XCAP.E_RST_TAIL 0.01355f
C5 XRX.XCAP.O_QBBUF VDD 6.75866f
C6 XRX.XFRONT.XFE_O.VREGN XRX.XFRONT.XFE_O.SXN 0.01502f
C7 XRX.XFRONT.XFE_E.NREGEN XRX.XFRONT.XFE_E.SXN 1.12793f
C8 XRX.XCAP.EVEN_DB_BUF E_CAPTURE_CLK 0.15269f
C9 XRX.XFRONT.XFE_E.NTAIL E_SENSE_BOOST 0.96944f
C10 VDD E_CAPTURE_CLK 2.30838f
C11 E_SENSE_CLK E_SENSE_BOOST 4.27044f
C12 FE_E_P E_REGEN_CLK 0.28385f
C13 XRX.XCAP.ODD_DB_BUF O_CAPTURE_CLKB 0.81461f
C14 XRX.XCAP.O_PRST_TAIL XRX.XCAP.O_PSET_TAIL 1.05443f
C15 XRX.XCAP.ODD_D_BUF ODD_QB 0.15391f
C16 VDD E_REGEN_CLKB 17.4356f
C17 XRX.XCAP.O_QBUF VDD 6.35692f
C18 VDD PI_RAW_P 0.11594f
C19 XRX.XCAP.E_QI E_CAPTURE_CLK 0.1853f
C20 EVEN_QB FE_E_P 0.07547f
C21 XRX.XFRONT.XFE_O.SB SAMP_O_N 0.77892f
C22 VDD RX_RESTN 0.41275f
C23 VDD O_CAPTURE_CLKB 10.3115f
C24 RXP RXN 0.49155f
C25 XRX.XCAP.EVEN_D_BUF XRX.XCAP.E_RST_TAIL 0.37995f
C26 XRX.XCAP.O_QBI XRX.XCAP.O_QI 8.49253f
C27 XRX.XCAP.ODD_D_BUF XRX.XCAP.O_SET_TAIL 0.53742f
C28 XRX.XCAP.E_QBI XRX.XCAP.E_SET_TAIL 4.91367f
C29 XRX.XCAP.EVEN_D_BUF FE_E_P 0.04189f
C30 XRX.XCAP.E_QBUF VDD 7.45153f
C31 XRX.XFRONT.XFE_O.SB XRX.XFRONT.XFE_O.SXP 0.01479f
C32 XRX.XFRONT.XFE_E.XP XRX.XFRONT.XFE_E.SXP 2.28757f
C33 PHASE_A_N PI_CTRL_B 0.13686f
C34 XRX.XFRONT.XFE_O.SA SAMP_O_N 0.05427f
C35 XRX.XFRONT.XFE_O.SB O_SENSE_CLK 1.27971f
C36 VDD SAMP_E_N 0.26142f
C37 XRX.XFRONT.XFE_E.XP SAMP_E_P 0.01394f
C38 XRX.XCAP.O_QBI XRX.XCAP.ODD_DB_BUF 0.19065f
C39 XRX.XCAP.E_PRST_TAIL XRX.XCAP.E_PSET_TAIL 1.95856f
C40 XRX.XCAP.E_QBUF XRX.XCAP.E_QI 0.06057f
C41 XRX.XCAP.O_PRST_TAIL XRX.XCAP.O_QI 0.29363f
C42 VDD TERM_EN4_N 1.84084f
C43 XRX.XCAP.E_QBBUF VDD 6.44257f
C44 XRX.XFRONT.XFE_E.SA XRX.XFRONT.XFE_E.NTAIL 3.62199f
C45 XRX.XFRONT.XFE_O.XN XRX.XFRONT.XFE_O.NREGEN 15.2443f
C46 XRX.XFRONT.XFE_E.XP XRX.XFRONT.XFE_E.SXN 0.18968f
C47 XRX.XFRONT.XFE_E.SA E_SENSE_CLK 2.78252f
C48 E_CAPTURE_CLK E_REGEN_CLKB 0.03197f
C49 XRX.XFRONT.XFE_O.SA O_SENSE_CLK 2.78252f
C50 XRX.XCAP.EVEN_DB_BUF FE_E_N 0.03785f
C51 XRX.XCAP.O_QBBUF O_CAPTURE_CLKB 0.16758f
C52 VDD FE_E_N 14.2791f
C53 RX_RAWN RX_BW_EN_N 0.3734f
C54 XRX.XCAP.E_QBBUF XRX.XCAP.E_QI 0.60128f
C55 XRX.XCAP.EVEN_D_BUF XRX.XCAP.E_SET_TAIL 0.61506f
C56 XRX.XCAP.O_PRST_TAIL XRX.XCAP.ODD_DB_BUF 0.86137f
C57 XRX.XCAP.ODD_D_BUF XRX.XCAP.O_PSET_TAIL 1.09217f
C58 XRX.XCAP.E_QBI XRX.XCAP.E_PSET_TAIL 0.20078f
C59 XRX.XFRONT.XFE_O.XP XRX.XFRONT.XFE_O.NREGEN 15.5907f
C60 XRX.XFRONT.XFE_O.VREGP XRX.XFRONT.XFE_O.SXP 0.03789f
C61 XRX.XFRONT.XFE_E.SB XRX.XFRONT.XFE_E.NTAIL 2.81419f
C62 XRX.XCAP.O_QBI VDD 8.61871f
C63 XRX.XFRONT.XFE_E.XN XRX.XFRONT.XFE_E.SXN 1.52306f
C64 XRX.XFRONT.XFE_E.SB E_SENSE_CLK 1.27971f
C65 VDD RX_RESTP 0.38423f
C66 VDD O_REGEN_CLKB 17.4356f
C67 TERM_EN5_N TERM_EN4_N 0.0465f
C68 XRX.XCAP.E_QI FE_E_N 0.52886f
C69 FE_O_P O_CAPTURE_CLK 0.2426f
C70 VDD RX_RAWP 1.26797f
C71 REST_BIAS RX_RAWP 0.25868f
C72 VDD PI_RAW_N 0.04221f
C73 XRX.XCAP.O_PRST_TAIL VDD 15.3528f
C74 XRX.XCAP.E_PSET_TAIL EVEN_QB 0.02064f
C75 E_CAPTURE_CLKB EVEN_Q 0.10117f
C76 XRX.XCAP.E_PRST_TAIL XRX.XCAP.EVEN_DB_BUF 0.13174f
C77 FE_E_N E_CAPTURE_CLK 0.57071f
C78 XRX.XCAP.EVEN_D_BUF XRX.XCAP.E_PSET_TAIL 0.4182f
C79 XRX.XCAP.ODD_D_BUF XRX.XCAP.O_QI 0.70423f
C80 ODD_QB FE_O_N 0.09326f
C81 SAMP_E_N RX_RESTN 0.21698f
C82 XRX.XCAP.E_PRST_TAIL VDD 16.0686f
C83 XRX.XFRONT.XFE_O.XP XRX.XFRONT.XFE_O.XN 18.0183f
C84 PI_BUF_BIAS PI_CTRL_B 0.13433f
C85 XRX.XFRONT.XFE_E.XP XRX.XFRONT.XFE_E.NREGEN 15.5907f
C86 VDD TERM_EN3_N 1.84084f
C87 RX_BIAS RXP 0.89265f
C88 VDD PI_CLK_P 0.76876f
C89 XRX.XCAP.E_PRST_TAIL XRX.XCAP.E_QI 0.2741f
C90 XRX.XCAP.E_QBI XRX.XCAP.EVEN_DB_BUF 0.0643f
C91 XRX.XCAP.ODD_D_BUF XRX.XCAP.ODD_DB_BUF 1.07149f
C92 XRX.XCAP.O_QBI XRX.XCAP.O_QBUF 1.08164f
C93 XRX.XFRONT.XFE_E.XN XRX.XFRONT.XFE_E.NREGEN 15.2443f
C94 XRX.XCAP.E_QBI VDD 8.57345f
C95 SAMP_E_P E_SENSE_BOOST 0.06659f
C96 VDD E_REGEN_CLK 21.5641f
C97 RX_RESTN RX_RESTP 4.19071f
C98 XRX.XCAP.O_QBI O_CAPTURE_CLKB 0.07731f
C99 PI_RAW_P PI_RAW_N 1.04714f
C100 PI_CLK_N SAMP_BIAS 1.47664f
C101 XRX.XCAP.E_QBI XRX.XCAP.E_QI 8.54354f
C102 XRX.XCAP.O_PRST_TAIL XRX.XCAP.O_QBUF 1.54979f
C103 XRX.XFRONT.XFE_E.VREGP XRX.XFRONT.XFE_E.SXP 0.03789f
C104 XRX.XCAP.ODD_D_BUF VDD 15.601f
C105 XRX.XFRONT.XFE_O.SB XRX.XFRONT.XFE_O.NREGEN 2.22508f
C106 XRX.XCAP.EVEN_DB_BUF EVEN_QB 0.15519f
C107 VDD EVEN_QB 8.86516f
C108 VDD SAMP_O_P 0.35499f
C109 XRX.XCAP.E_QBBUF FE_E_N 0.14911f
C110 XRX.XCAP.O_PRST_TAIL O_CAPTURE_CLKB 3.41065f
C111 SAMP_E_N RX_RESTP 0.17266f
C112 XRX.XCAP.EVEN_D_BUF XRX.XCAP.EVEN_DB_BUF 0.97829f
C113 XRX.XCAP.EVEN_D_BUF VDD 14.4594f
C114 XRX.XFRONT.XFE_O.VREGN XRX.XFRONT.XFE_O.XN 9.76051f
C115 XRX.XFRONT.XFE_O.SA XRX.XFRONT.XFE_O.NREGEN 2.62097f
C116 XRX.XCAP.E_QI EVEN_QB 0.33632f
C117 XRX.XFRONT.XFE_O.SB O_SENSE_BOOST 0.17061f
C118 VDD TERM_EN2_N 1.84084f
C119 XRX.XFRONT.XFE_E.SA SAMP_E_P 0.05427f
C120 E_CAPTURE_CLK E_REGEN_CLK 0.0157f
C121 XRX.XCAP.E_PRST_TAIL XRX.XCAP.E_QBUF 0.53754f
C122 XRX.XCAP.ODD_D_BUF XRX.XCAP.O_QBBUF 2.37715f
C123 XRX.XCAP.EVEN_D_BUF XRX.XCAP.E_QI 0.74882f
C124 XRX.XFRONT.XFE_O.VREGN XRX.XFRONT.XFE_O.XP 1.71293f
C125 XRX.XFRONT.XFE_E.SB XRX.XFRONT.XFE_E.SXP 0.01479f
C126 XRX.XFRONT.XFE_O.SB XRX.XFRONT.XFE_O.XN 3.3005f
C127 XRX.XFRONT.XFE_O.VREGP XRX.XFRONT.XFE_O.NREGEN 0.01091f
C128 XRX.XFRONT.XFE_E.XN XRX.XFRONT.XFE_E.XP 18.0183f
C129 XRX.XFRONT.XFE_O.SA O_SENSE_BOOST 0.04435f
C130 E_REGEN_CLKB E_REGEN_CLK 5.87024f
C131 XRX.XFRONT.XFE_E.SB SAMP_E_P 0.77892f
C132 XRX.XCAP.O_QI FE_O_N 0.57789f
C133 XRX.XCAP.E_QBI XRX.XCAP.E_QBUF 0.99299f
C134 XRX.XCAP.O_PRST_TAIL XRX.XCAP.O_QBI 5.53402f
C135 XRX.XCAP.ODD_D_BUF XRX.XCAP.O_QBUF 0.28842f
C136 VDD O_REGEN_CLK 21.5641f
C137 XRX.XFRONT.XFE_O.SB XRX.XFRONT.XFE_O.XP 2.02624f
C138 XRX.XFRONT.XFE_O.SA XRX.XFRONT.XFE_O.XN 2.02785f
C139 TERM_EN4_N TERM_EN3_N 0.0465f
C140 XRX.XCAP.EVEN_D_BUF E_CAPTURE_CLK 0.10379f
C141 XRX.XCAP.ODD_D_BUF O_CAPTURE_CLKB 0.70031f
C142 SAMP_O_P RX_RESTN 0.17429f
C143 XRX.XFRONT.XFE_E.VREGP XRX.XFRONT.XFE_E.NREGEN 0.01091f
C144 XRX.XFRONT.XFE_E.VREGN XRX.XFRONT.XFE_E.SXN 0.01502f
C145 XRX.XFRONT.XFE_O.SA XRX.XFRONT.XFE_O.XP 2.75504f
C146 XRX.XFRONT.XFE_O.VREGP XRX.XFRONT.XFE_O.XN 1.41685f
C147 XRX.XCAP.E_QBUF EVEN_QB 4.13702f
C148 PHASE_A_P PI_CTRL_A 0.14136f
C149 RX_RESTP PI_CLK_P 0.38527f
C150 VDD TERM_EN1_N 1.84084f
C151 VDD FE_O_N 14.4285f
C152 XRX.XFRONT.XFE_E.SA XRX.XFRONT.XFE_E.NREGEN 2.62097f
C153 XRX.XFRONT.XFE_O.VREGP XRX.XFRONT.XFE_O.XP 9.69939f
C154 XRX.XCAP.E_QBBUF EVEN_QB 0.17621f
C155 XRX.XCAP.ODD_D_BUF XRX.XCAP.O_QBI 4.78972f
C156 XRX.XCAP.EVEN_D_BUF XRX.XCAP.E_QBBUF 2.27875f
C157 ODD_QB ODD_Q 0.51937f
C158 EVEN_QB FE_E_N 0.06902f
C159 XRX.XFRONT.XFE_E.SB XRX.XFRONT.XFE_E.NREGEN 2.22508f
C160 XRX.XFRONT.XFE_E.SXN FE_E_P 0.13551f
C161 VDD E_SENSE_CLK 3.1142f
C162 SAMP_O_P RX_RESTP 0.10098f
C163 XRX.XCAP.EVEN_D_BUF FE_E_N 3.45509f
C164 XRX.XCAP.O_QBBUF FE_O_N 0.20592f
C165 XRX.XCAP.ODD_D_BUF XRX.XCAP.O_PRST_TAIL 0.78807f
C166 XRX.XCAP.E_QBI XRX.XCAP.E_PRST_TAIL 5.5293f
C167 XRX.XFRONT.XFE_E.VREGP XRX.XFRONT.XFE_E.XP 9.69939f
C168 XRX.XFRONT.XFE_E.BN FE_E_P 3.20364f
C169 XRX.XFRONT.XFE_O.BN VDD 6.76697f
C170 RXP TERM_EN6_N 0.32905f
C171 VDD RX_BW_EN_N 3.19847f
C172 XRX.XFRONT.XFE_E.VREGP XRX.XFRONT.XFE_E.XN 1.41685f
C173 XRX.XFRONT.XFE_E.SA XRX.XFRONT.XFE_E.XP 2.75504f
C174 XRX.XFRONT.XFE_O.SA XRX.XFRONT.XFE_O.SB 4.61805f
C175 XRX.XCAP.O_RST_TAIL O_CAPTURE_CLK 2.06628f
C176 XRX.XFRONT.XFE_O.SXN VDD 12.5413f
C177 VDD TERM_EN0_N 1.71963f
C178 XRX.XCAP.E_PRST_TAIL EVEN_QB 0.0844f
C179 PHASE_B_P PI_CTRL_A 0.14849f
C180 VDD SAMP_O_N 0.35499f
C181 O_CAPTURE_CLKB FE_O_N 0.16304f
C182 XRX.XCAP.EVEN_D_BUF XRX.XCAP.E_PRST_TAIL 3.77728f
C183 VDD RXP 0.72204f
C184 XRX.XFRONT.XFE_E.SB XRX.XFRONT.XFE_E.XP 2.02624f
C185 XRX.XFRONT.XFE_E.SA XRX.XFRONT.XFE_E.XN 2.02785f
C186 O_REGEN_CLKB O_REGEN_CLK 5.87024f
C187 E_REGEN_CLKB E_SENSE_CLK 0.01888f
C188 XRX.XFRONT.XFE_O.SXP VDD 12.5687f
C189 XRX.XCAP.E_QBI EVEN_QB 0.15538f
C190 XRX.XCAP.O_RST_TAIL FE_O_P 0.16401f
C191 VDD O_SENSE_CLK 3.1142f
C192 TERM_EN3_N TERM_EN2_N 0.0465f
C193 XRX.XCAP.EVEN_D_BUF XRX.XCAP.E_QBI 4.77076f
C194 E_CAPTURE_CLKB FE_E_P 0.28347f
C195 XRX.XFRONT.XFE_E.VREGN XRX.XFRONT.XFE_E.XP 1.71293f
C196 XRX.XFRONT.XFE_E.SB XRX.XFRONT.XFE_E.XN 3.3005f
C197 XRX.XFRONT.XFE_O.VREGP XRX.XFRONT.XFE_O.SA 0.01053f
C198 XRX.XCAP.O_SET_TAIL O_CAPTURE_CLK 1.51208f
C199 XRX.XFRONT.XFE_O.BP VDD 6.76837f
C200 VDD VTHP 0.93005f
C201 RXP TERM_EN5_N 0.3225f
C202 ODD_QB FE_O_P 0.10247f
C203 XRX.XFRONT.XFE_E.NTAIL SAMP_E_N 1.1378f
C204 E_SENSE_CLK SAMP_E_N 0.30032f
C205 XRX.XFRONT.XFE_E.VREGN XRX.XFRONT.XFE_E.XN 9.76051f
C206 FE_O_N O_REGEN_CLKB 0.19768f
C207 XRX.XFRONT.XFE_E.BP VDD 6.76837f
C208 XRX.XCAP.EVEN_D_BUF EVEN_QB 0.13958f
C209 RX_BIAS RXN 0.36689f
C210 SAMP_O_N RX_RESTN 0.01966f
C211 XRX.XFRONT.XFE_E.SXP VDD 12.5687f
C212 XRX.XFRONT.XFE_E.SA E_SENSE_BOOST 0.04435f
C213 PHASE_B_N PI_CTRL_A 0.01829f
C214 VDD CLK_REST_BIAS 0.20024f
C215 VDD SAMP_E_P 0.26142f
C216 RX_RESTN SAMP_BIAS 0.01215f
C217 VDD ODD_Q 7.41927f
C218 XRX.XFRONT.XFE_E.SXN VDD 12.5413f
C219 XRX.XFRONT.XFE_O.BN O_REGEN_CLKB 0.10264f
C220 XRX.XFRONT.XFE_E.SB E_SENSE_BOOST 0.17061f
C221 RXP TERM_EN4_N 0.3225f
C222 XRX.XCAP.E_PSET_TAIL E_CAPTURE_CLKB 3.32426f
C223 RX_RAWP RX_BW_EN_N 0.3734f
C224 XRX.XFRONT.XFE_E.SA XRX.XFRONT.XFE_E.VREGP 0.01053f
C225 XRX.XCAP.O_QI O_CAPTURE_CLK 0.16467f
C226 XRX.XFRONT.XFE_E.BN VDD 6.76697f
C227 XRX.XFRONT.XFE_O.SXN O_REGEN_CLKB 0.24469f
C228 SAMP_O_N RX_RESTP 0.21629f
C229 PHASE_A_P PHASE_B_P 0.41197f
C230 XRX.XCAP.O_QBBUF ODD_Q 4.18276f
C231 XRX.XCAP.ODD_D_BUF FE_O_N 3.44145f
C232 XRX.XFRONT.XFE_E.SXP E_REGEN_CLKB 0.14644f
C233 XRX.XFRONT.XFE_O.NREGEN VDD 9.02169f
C234 XRX.XCAP.ODD_DB_BUF O_CAPTURE_CLK 0.32291f
C235 XRX.XFRONT.XFE_O.SXP O_REGEN_CLKB 0.14644f
C236 CLK_REST_BIAS PI_RAW_P 0.13683f
C237 XRX.XCAP.O_QI FE_O_P 0.12934f
C238 XRX.XFRONT.XFE_O.NTAIL SAMP_O_P 1.1378f
C239 XRX.XFRONT.XFE_E.NTAIL E_REGEN_CLK 0.05461f
C240 O_REGEN_CLKB O_SENSE_CLK 0.01888f
C241 E_REGEN_CLK E_SENSE_CLK 0.05769f
C242 XRX.XFRONT.XFE_E.SXN E_REGEN_CLKB 0.24469f
C243 XRX.XFRONT.XFE_E.SB XRX.XFRONT.XFE_E.SA 4.61805f
C244 XRX.XFRONT.XFE_E.NREGEN VDD 9.02169f
C245 VDD O_CAPTURE_CLK 2.30876f
C246 SAMP_E_P RX_RESTN 0.42621f
C247 TERM_EN2_N TERM_EN1_N 0.0465f
C248 XRX.XCAP.ODD_DB_BUF FE_O_P 3.64424f
C249 O_CAPTURE_CLKB ODD_Q 0.07511f
C250 XRX.XFRONT.XFE_E.BP FE_E_N 2.97395f
C251 XRX.XCAP.EVEN_DB_BUF E_CAPTURE_CLKB 0.19022f
C252 XRX.XFRONT.XFE_E.BN E_REGEN_CLKB 0.10264f
C253 VDD E_CAPTURE_CLKB 10.4761f
C254 RXP TERM_EN3_N 0.3225f
C255 XRX.XFRONT.XFE_O.XN VDD 23.0487f
C256 SAMP_E_P SAMP_E_N 5.05443f
C257 VDD FE_O_P 14.3026f
C258 VDD EVEN_Q 7.31561f
C259 FE_O_N O_REGEN_CLK 0.28385f
C260 XRX.XCAP.E_QI E_CAPTURE_CLKB 0.15555f
C261 XRX.XFRONT.XFE_O.NTAIL O_REGEN_CLK 0.05461f
C262 PI_CLK_P SAMP_BIAS 2.0425f
C263 XRX.XFRONT.XFE_O.XP VDD 24.8188f
C264 VDD VTHN 0.51765f
C265 SAMP_E_P RX_RESTP 0.05468f
C266 SAMP_O_P SAMP_O_N 5.12811f
C267 XRX.XFRONT.XFE_E.NREGEN E_REGEN_CLKB 0.18411f
C268 CLK_REST_BIAS PI_RAW_N 0.11403f
C269 XRX.XFRONT.XFE_E.XP VDD 24.8188f
C270 E_CAPTURE_CLKB E_CAPTURE_CLK 2.90086f
C271 O_CAPTURE_CLKB O_CAPTURE_CLK 3.07408f
C272 XRX.XFRONT.XFE_O.BN O_REGEN_CLK 0.12159f
C273 O_SENSE_CLK SAMP_O_P 0.30032f
C274 XRX.XFRONT.XFE_E.XN VDD 23.0487f
C275 RXP TERM_EN2_N 0.3225f
C276 XRX.XFRONT.XFE_E.NREGEN SAMP_E_N 0.0139f
C277 XRX.XFRONT.XFE_O.SXN O_REGEN_CLK 0.28429f
C278 XRX.XFRONT.XFE_O.VREGN VDD 12.591f
C279 XRX.XFRONT.XFE_O.NREGEN O_REGEN_CLKB 0.18411f
C280 XRX.XFRONT.XFE_E.SXP E_REGEN_CLK 0.39898f
C281 XRX.XCAP.E_QBBUF E_CAPTURE_CLKB 0.15018f
C282 XRX.XFRONT.XFE_O.SXP O_REGEN_CLK 0.39898f
C283 XRX.XFRONT.XFE_O.BN FE_O_N 3.20364f
C284 XRX.XFRONT.XFE_E.XP E_REGEN_CLKB 0.41303f
C285 XRX.XCAP.O_QBI O_CAPTURE_CLK 0.04327f
C286 XRX.XFRONT.XFE_O.SB VDD 6.44275f
C287 XRX.XFRONT.XFE_E.NTAIL E_SENSE_CLK 0.93342f
C288 O_REGEN_CLK O_SENSE_CLK 0.05769f
C289 O_CAPTURE_CLK O_REGEN_CLKB 0.03197f
C290 XRX.XCAP.E_QBBUF EVEN_Q 4.25991f
C291 E_CAPTURE_CLKB FE_E_N 0.12139f
C292 XRX.XFRONT.XFE_E.SXN E_REGEN_CLK 0.28429f
C293 PHASE_B_P PHASE_B_N 0.27529f
C294 PI_CTRL_A PI_CTRL_B 0.01148f
C295 XRX.XFRONT.XFE_O.SXN FE_O_N 0.13551f
C296 TERM_EN1_N TERM_EN0_N 0.0465f
C297 XRX.XFRONT.XFE_E.XN E_REGEN_CLKB 0.27371f
C298 XRX.XCAP.O_SET_TAIL XRX.XCAP.O_RST_TAIL 0.70351f
C299 XRX.XFRONT.XFE_O.SA VDD 7.16352f
C300 XRX.XFRONT.XFE_O.XN O_REGEN_CLKB 0.27371f
C301 XRX.XFRONT.XFE_O.NTAIL SAMP_O_N 1.30545f
C302 XRX.XFRONT.XFE_E.BN E_REGEN_CLK 0.12159f
C303 RXP TERM_EN1_N 0.30522f
C304 XRX.XFRONT.XFE_O.VREGP VDD 13.9312f
C305 XRX.XFRONT.XFE_O.XP O_REGEN_CLKB 0.41303f
C306 XRX.XFRONT.XFE_O.NTAIL O_SENSE_CLK 0.93342f
C307 XRX.XFRONT.XFE_E.XN SAMP_E_N 0.02387f
C308 XRX.XCAP.E_PRST_TAIL E_CAPTURE_CLKB 0.94605f
C309 XRX.XCAP.E_SET_TAIL XRX.XCAP.E_RST_TAIL 0.57545f
C310 XRX.XFRONT.XFE_O.SXN XRX.XFRONT.XFE_O.BN 2.55502f
C311 XRX.XFRONT.XFE_E.VREGP VDD 13.9312f
C312 XRX.XFRONT.XFE_O.NREGEN SAMP_O_P 0.0139f
C313 VDD RX_RAWN 1.26797f
C314 XRX.XFRONT.XFE_E.NREGEN E_REGEN_CLK 2.24204f
C315 REST_BIAS RX_RAWN 0.11711f
C316 XRX.XCAP.E_QBI E_CAPTURE_CLKB 0.12357f
C317 XRX.XFRONT.XFE_E.SA VDD 7.16352f
C318 XRX.XCAP.ODD_D_BUF O_CAPTURE_CLK 0.0367f
C319 XRX.XCAP.O_PSET_TAIL ODD_QB 0.21495f
C320 SAMP_O_P O_SENSE_BOOST 0.05905f
C321 XRX.XCAP.O_QI XRX.XCAP.O_RST_TAIL 4.94403f
C322 RXP TERM_EN0_N 0.29398f
C323 XRX.XFRONT.XFE_E.SB VDD 6.44275f
C324 E_CAPTURE_CLKB EVEN_QB 0.70057f
C325 XRX.XFRONT.XFE_O.VREGN O_REGEN_CLKB 2.28169f
C326 XRX.XCAP.ODD_D_BUF FE_O_P 0.02446f
C327 RX_BW_EN_N VTHP 0.14804f
C328 XRX.XFRONT.XFE_O.XN SAMP_O_P 0.02387f
C329 VDD PI_CLK_N 1.06379f
C330 EVEN_Q EVEN_QB 0.47433f
C331 XRX.XCAP.EVEN_D_BUF E_CAPTURE_CLKB 0.42228f
C332 O_SENSE_CLK SAMP_O_N 5.05623f
C333 XRX.XFRONT.XFE_O.NREGEN O_REGEN_CLK 2.24204f
C334 SAMP_E_N E_SENSE_BOOST 0.05905f
C335 XRX.XFRONT.XFE_E.VREGP E_REGEN_CLKB 3.66341f
C336 XRX.XCAP.ODD_DB_BUF XRX.XCAP.O_RST_TAIL 0.56945f
C337 XRX.XCAP.O_QI ODD_QB 0.23682f
C338 XRX.XFRONT.XFE_E.VREGN VDD 12.591f
C339 XRX.XFRONT.XFE_O.SB O_REGEN_CLKB 0.16909f
C340 XRX.XFRONT.XFE_E.XP E_REGEN_CLK 2.97989f
C341 XRX.XFRONT.XFE_E.NTAIL SAMP_E_P 1.30545f
C342 E_SENSE_CLK SAMP_E_P 5.05623f
C343 O_CAPTURE_CLK O_REGEN_CLK 0.0157f
C344 XRX.XCAP.O_QI XRX.XCAP.O_SET_TAIL 0.48793f
C345 XRX.XFRONT.XFE_E.SA E_REGEN_CLKB 0.23634f
C346 XRX.XCAP.ODD_DB_BUF ODD_QB 0.17063f
C347 XRX.XFRONT.XFE_O.BP XRX.XFRONT.XFE_O.SXP 2.48339f
C348 XRX.XFRONT.XFE_O.SA O_REGEN_CLKB 0.23634f
C349 XRX.XFRONT.XFE_E.XN E_REGEN_CLK 2.93387f
C350 XRX.XFRONT.XFE_O.XN O_REGEN_CLK 2.93387f
C351 XRX.XFRONT.XFE_E.SB E_REGEN_CLKB 0.16909f
C352 XRX.XCAP.EVEN_DB_BUF XRX.XCAP.E_RST_TAIL 0.50524f
C353 XRX.XCAP.ODD_DB_BUF XRX.XCAP.O_SET_TAIL 0.54226f
C354 XRX.XCAP.EVEN_DB_BUF FE_E_P 3.50536f
C355 XRX.XFRONT.XFE_O.NREGEN XRX.XFRONT.XFE_O.NTAIL 0.05705f
C356 VDD FE_E_P 14.5006f
C357 VDD ODD_QB 7.42733f
C358 XRX.XFRONT.XFE_O.VREGP O_REGEN_CLKB 3.66341f
C359 XRX.XFRONT.XFE_E.SA SAMP_E_N 0.90873f
C360 PHASE_B_N PHASE_A_N 0.41197f
C361 XRX.XFRONT.XFE_O.XP O_REGEN_CLK 2.97989f
C362 XRX.XFRONT.XFE_E.VREGN E_REGEN_CLKB 2.28169f
C363 XRX.XCAP.E_QI XRX.XCAP.E_RST_TAIL 4.88428f
C364 XRX.XCAP.O_QI XRX.XCAP.O_PSET_TAIL 5.10737f
C365 FE_O_N O_CAPTURE_CLK 0.52071f
C366 RX_RESTN PI_CLK_N 0.09294f
C367 XRX.XCAP.E_QI FE_E_P 0.09054f
C368 XRX.XFRONT.XFE_O.NTAIL O_SENSE_BOOST 0.96944f
C369 XRX.XFRONT.XFE_E.SB SAMP_E_N 0.04213f
C370 XRX.XCAP.EVEN_DB_BUF XRX.XCAP.E_SET_TAIL 0.71109f
C371 XRX.XCAP.ODD_DB_BUF XRX.XCAP.O_PSET_TAIL 0.68175f
C372 XRX.XCAP.O_QBBUF ODD_QB 0.15023f
C373 XRX.XFRONT.XFE_E.NREGEN XRX.XFRONT.XFE_E.NTAIL 0.05705f
C374 RX_RAWP RX_RAWN 0.58235f
C375 XRX.XFRONT.XFE_E.NREGEN E_SENSE_CLK 0.11224f
C376 XRX.XCAP.E_RST_TAIL E_CAPTURE_CLK 1.16209f
C377 FE_E_P E_CAPTURE_CLK 0.4521f
C378 FE_O_P FE_O_N 2.27142f
C379 XRX.XFRONT.XFE_O.SB SAMP_O_P 0.04213f
C380 XRX.XCAP.E_QI XRX.XCAP.E_SET_TAIL 0.76857f
C381 FE_E_P E_REGEN_CLKB 0.19768f
C382 XRX.XCAP.O_QBUF ODD_QB 4.17728f
C383 XRX.XCAP.O_PSET_TAIL VDD 13.1964f
C384 XRX.XFRONT.XFE_O.NREGEN XRX.XFRONT.XFE_O.SXN 1.12793f
C385 XRX.XFRONT.XFE_E.SXP XRX.XFRONT.XFE_E.BP 2.48339f
C386 PHASE_B_P PI_CTRL_B 0.02033f
C387 XRX.XFRONT.XFE_O.NREGEN SAMP_O_N 0.01317f
C388 XRX.XFRONT.XFE_O.SA SAMP_O_P 0.90873f
C389 RX_RESTP PI_CLK_N 0.02351f
C390 O_CAPTURE_CLKB ODD_QB 0.10357f
C391 XRX.XCAP.EVEN_DB_BUF XRX.XCAP.E_PSET_TAIL 1.81361f
C392 XRX.XCAP.ODD_DB_BUF XRX.XCAP.O_QI 3.71826f
C393 XRX.XCAP.E_PSET_TAIL VDD 11.6748f
C394 XRX.XFRONT.XFE_O.NREGEN XRX.XFRONT.XFE_O.SXP 0.43552f
C395 XRX.XCAP.E_SET_TAIL E_CAPTURE_CLK 1.75694f
C396 XRX.XFRONT.XFE_O.NREGEN O_SENSE_CLK 0.11224f
C397 SAMP_O_N O_SENSE_BOOST 0.06659f
C398 XRX.XFRONT.XFE_O.SB O_REGEN_CLK 0.27286f
C399 XRX.XCAP.E_QI XRX.XCAP.E_PSET_TAIL 5.13429f
C400 XRX.XCAP.O_QBI XRX.XCAP.O_RST_TAIL 0.0736f
C401 XRX.XCAP.O_QI VDD 7.2336f
C402 XRX.XFRONT.XFE_O.XN XRX.XFRONT.XFE_O.SXN 1.52306f
C403 XRX.XFRONT.XFE_E.XP E_SENSE_CLK 0.15824f
C404 VDD TERM_EN6_N 1.78028f
C405 XRX.XFRONT.XFE_E.SA E_REGEN_CLK 0.34023f
C406 XRX.XCAP.E_RST_TAIL FE_E_N 0.046f
C407 FE_E_N FE_E_P 3.5147f
C408 RX_BW_EN_N VTHN 0.52758f
C409 O_SENSE_CLK O_SENSE_BOOST 4.27044f
C410 XRX.XFRONT.XFE_O.SA O_REGEN_CLK 0.34023f
C411 XRX.XCAP.O_QBUF XRX.XCAP.O_PSET_TAIL 0.04525f
C412 XRX.XCAP.O_QBI ODD_QB 0.15666f
C413 XRX.XFRONT.XFE_O.XP XRX.XFRONT.XFE_O.SXN 0.18968f
C414 XRX.XCAP.ODD_DB_BUF VDD 13.0218f
C415 XRX.XFRONT.XFE_E.XN E_SENSE_CLK 1.26026f
C416 PI_CLK_P PI_CLK_N 9.08661f
C417 XRX.XFRONT.XFE_O.XP SAMP_O_N 0.01394f
C418 XRX.XFRONT.XFE_O.XN O_SENSE_CLK 1.26026f
C419 XRX.XFRONT.XFE_E.SB E_REGEN_CLK 0.27286f
C420 XRX.XCAP.O_PSET_TAIL O_CAPTURE_CLKB 2.02608f
C421 TERM_EN6_N TERM_EN5_N 0.0465f
C422 XRX.XCAP.O_QBBUF XRX.XCAP.O_QI 0.68141f
C423 XRX.XCAP.O_QBI XRX.XCAP.O_SET_TAIL 4.91815f
C424 XRX.XCAP.EVEN_DB_BUF VDD 12.9418f
C425 XRX.XCAP.O_PRST_TAIL ODD_QB 0.43511f
C426 XRX.XFRONT.XFE_O.XP XRX.XFRONT.XFE_O.SXP 2.28757f
C427 XRX.XFRONT.XFE_E.BN XRX.XFRONT.XFE_E.SXN 2.55502f
C428 XRX.XFRONT.XFE_O.SB XRX.XFRONT.XFE_O.NTAIL 2.81419f
C429 PHASE_B_N PI_CTRL_B 0.1441f
C430 VDD REST_BIAS 0.20996f
C431 XRX.XFRONT.XFE_O.XP O_SENSE_CLK 0.15824f
C432 XRX.XFRONT.XFE_O.BP FE_O_P 2.97395f
C433 XRX.XCAP.E_QI XRX.XCAP.EVEN_DB_BUF 3.57751f
C434 XRX.XCAP.E_QI VDD 7.23216f
C435 XRX.XFRONT.XFE_E.NREGEN XRX.XFRONT.XFE_E.SXP 0.43552f
C436 XRX.XFRONT.XFE_O.SA XRX.XFRONT.XFE_O.NTAIL 3.62199f
C437 XRX.XCAP.O_QI O_CAPTURE_CLKB 0.15737f
C438 VTHP VTHN 1.695f
C439 TERM_EN0_N VSS 3.16281f
C440 TERM_EN1_N VSS 2.58106f
C441 TERM_EN2_N VSS 2.56583f
C442 TERM_EN3_N VSS 2.56561f
C443 TERM_EN4_N VSS 2.56561f
C444 TERM_EN5_N VSS 2.56561f
C445 TERM_EN6_N VSS 2.69513f
C446 RXN VSS 15.24638f
C447 RXP VSS 15.17772f
C448 RX_BIAS VSS 13.3368f
C449 VTHN VSS 5.17466f
C450 VTHP VSS 5.04058f
C451 RX_BW_EN_N VSS 4.30524f
C452 RX_RAWN VSS 11.07534f
C453 RX_RAWP VSS 11.20287f
C454 PI_CTRL_B VSS 4.65024f
C455 PI_CTRL_A VSS 3.45407f
C456 PI_BUF_BIAS VSS 2.78969f
C457 PHASE_A_N VSS 2.73702f
C458 PHASE_B_N VSS 2.92306f
C459 PHASE_B_P VSS 2.86471f
C460 PHASE_A_P VSS 2.8479f
C461 PI_RAW_N VSS 21.74305f
C462 PI_RAW_P VSS 18.58269f
C463 REST_BIAS VSS 10.07665f
C464 CLK_REST_BIAS VSS 6.04268f
C465 SAMP_BIAS VSS 13.87178f
C466 PI_CLK_N VSS 33.96273f
C467 PI_CLK_P VSS 34.31174f
C468 RX_RESTP VSS 14.02047f
C469 RX_RESTN VSS 13.0766f
C470 O_SENSE_BOOST VSS 7.77216f
C471 SAMP_O_N VSS 23.62455f
C472 SAMP_O_P VSS 21.78121f
C473 E_SENSE_BOOST VSS 7.77215f
C474 SAMP_E_N VSS 21.54272f
C475 SAMP_E_P VSS 23.6221f
C476 O_SENSE_CLK VSS 10.59916f
C477 E_SENSE_CLK VSS 10.59916f
C478 O_REGEN_CLK VSS 13.62457f
C479 E_REGEN_CLK VSS 13.62457f
C480 O_REGEN_CLKB VSS 4.42478f
C481 E_REGEN_CLKB VSS 4.42478f
C482 O_CAPTURE_CLK VSS 27.65829f
C483 E_CAPTURE_CLK VSS 26.77125f
C484 FE_O_N VSS 29.84371f
C485 FE_O_P VSS 36.52533f
C486 FE_E_P VSS 39.02157f
C487 FE_E_N VSS 28.76325f
C488 ODD_Q VSS 5.29541f
C489 ODD_QB VSS 9.73643f
C490 EVEN_QB VSS 9.40271f
C491 EVEN_Q VSS 5.60206f
C492 O_CAPTURE_CLKB VSS 24.58366f
C493 E_CAPTURE_CLKB VSS 27.1192f
C494 VDD VSS 4.72597p
C495 XRX.XFRONT.XFE_O.NTAIL VSS 14.09834f
C496 XRX.XFRONT.XFE_E.NTAIL VSS 14.6349f
C497 XRX.XFRONT.XFE_O.BN VSS 15.10208f
C498 XRX.XFRONT.XFE_O.SXN VSS 12.96782f
C499 XRX.XFRONT.XFE_O.SXP VSS 13.11247f
C500 XRX.XFRONT.XFE_O.BP VSS 14.72881f
C501 XRX.XFRONT.XFE_E.BP VSS 15.07135f
C502 XRX.XFRONT.XFE_E.SXP VSS 14.89757f
C503 XRX.XFRONT.XFE_E.SXN VSS 13.51859f
C504 XRX.XFRONT.XFE_E.BN VSS 15.5139f
C505 XRX.XFRONT.XFE_O.NREGEN VSS 16.31945f
C506 XRX.XFRONT.XFE_E.NREGEN VSS 16.79713f
C507 XRX.XFRONT.XFE_O.XN VSS 8.1339f
C508 XRX.XFRONT.XFE_O.XP VSS 8.86716f
C509 XRX.XFRONT.XFE_E.XP VSS 9.30753f
C510 XRX.XFRONT.XFE_E.XN VSS 9.22271f
C511 XRX.XFRONT.XFE_O.VREGN VSS 0.31123f
C512 XRX.XFRONT.XFE_O.SB VSS 9.74535f
C513 XRX.XFRONT.XFE_O.SA VSS 10.5446f
C514 XRX.XFRONT.XFE_O.VREGP VSS 0.30873f
C515 XRX.XFRONT.XFE_E.VREGP VSS 2.16504f
C516 XRX.XFRONT.XFE_E.SA VSS 11.29091f
C517 XRX.XFRONT.XFE_E.SB VSS 11.02386f
C518 XRX.XFRONT.XFE_E.VREGN VSS 0.31123f
C519 XRX.XCAP.O_RST_TAIL VSS 14.07771f
C520 XRX.XCAP.E_RST_TAIL VSS 13.39814f
C521 XRX.XCAP.O_SET_TAIL VSS 11.53561f
C522 XRX.XCAP.E_SET_TAIL VSS 11.52819f
C523 XRX.XCAP.O_PSET_TAIL VSS 0.23222f
C524 XRX.XCAP.E_PSET_TAIL VSS 0.15708f
C525 XRX.XCAP.O_QI VSS 12.92219f
C526 XRX.XCAP.ODD_DB_BUF VSS 9.95341f
C527 XRX.XCAP.EVEN_DB_BUF VSS 10.21407f
C528 XRX.XCAP.E_QI VSS 12.05735f
C529 XRX.XCAP.O_QBBUF VSS 5.49643f
C530 XRX.XCAP.O_QBUF VSS 5.2576f
C531 XRX.XCAP.E_QBUF VSS 5.25384f
C532 XRX.XCAP.E_QBBUF VSS 6.1426f
C533 XRX.XCAP.O_QBI VSS 10.93681f
C534 XRX.XCAP.O_PRST_TAIL VSS 0.25427f
C535 XRX.XCAP.E_PRST_TAIL VSS 0.70236f
C536 XRX.XCAP.E_QBI VSS 11.57233f
C537 XRX.XCAP.ODD_D_BUF VSS 9.0285f
C538 XRX.XCAP.EVEN_D_BUF VSS 9.21535f
C539 XRX.XCAP.EVEN_D_BUF.n0 VSS 0.33788f
C540 XRX.XCAP.EVEN_D_BUF.n1 VSS 0.16701f
C541 XRX.XCAP.EVEN_D_BUF.n2 VSS 0.17902f
C542 XRX.XCAP.EVEN_D_BUF.n3 VSS 0.17902f
C543 XRX.XCAP.EVEN_D_BUF.n4 VSS 0.16919f
C544 XRX.XCAP.EVEN_D_BUF.n5 VSS 2.35913f
C545 XRX.XCAP.EVEN_D_BUF.n6 VSS 0.33788f
C546 XRX.XCAP.EVEN_D_BUF.n7 VSS 0.16701f
C547 XRX.XCAP.EVEN_D_BUF.n8 VSS 0.17902f
C548 XRX.XCAP.EVEN_D_BUF.n9 VSS 0.17902f
C549 XRX.XCAP.EVEN_D_BUF.n10 VSS 0.16919f
C550 XRX.XCAP.EVEN_D_BUF.n11 VSS 1.74907f
C551 XRX.XCAP.EVEN_D_BUF.n12 VSS 6.49512f
C552 XRX.XCAP.EVEN_D_BUF.t7 VSS 1.37889f
C553 XRX.XCAP.EVEN_D_BUF.t6 VSS 0.27794f
C554 XRX.XCAP.EVEN_D_BUF.t5 VSS 0.27794f
C555 XRX.XCAP.EVEN_D_BUF.n13 VSS 1.05804f
C556 XRX.XCAP.EVEN_D_BUF.n14 VSS 0.58157f
C557 XRX.XCAP.EVEN_D_BUF.t4 VSS 0.27794f
C558 XRX.XCAP.EVEN_D_BUF.t3 VSS 0.27794f
C559 XRX.XCAP.EVEN_D_BUF.n15 VSS 1.05804f
C560 XRX.XCAP.EVEN_D_BUF.n16 VSS 0.24385f
C561 XRX.XCAP.EVEN_D_BUF.t0 VSS 1.37889f
C562 XRX.XCAP.EVEN_D_BUF.t2 VSS 0.27794f
C563 XRX.XCAP.EVEN_D_BUF.t1 VSS 0.27794f
C564 XRX.XCAP.EVEN_D_BUF.n17 VSS 1.05804f
C565 XRX.XCAP.EVEN_D_BUF.n18 VSS 0.52182f
C566 XRX.XCAP.EVEN_D_BUF.n19 VSS 0.11987f
C567 XRX.XCAP.EVEN_D_BUF.t11 VSS 1.37637f
C568 XRX.XCAP.EVEN_D_BUF.t10 VSS 0.27794f
C569 XRX.XCAP.EVEN_D_BUF.t9 VSS 0.27794f
C570 XRX.XCAP.EVEN_D_BUF.n20 VSS 1.05024f
C571 XRX.XCAP.EVEN_D_BUF.n21 VSS 0.53215f
C572 XRX.XCAP.EVEN_D_BUF.t8 VSS 1.37069f
C573 XRX.XCAP.EVEN_D_BUF.n22 VSS 1.1256f
C574 XRX.XCAP.EVEN_D_BUF.n23 VSS 2.00092f
C575 XRX.XCAP.EVEN_D_BUF.n24 VSS 0.91313f
C576 XRX.XCAP.ODD_D_BUF.t11 VSS 1.34525f
C577 XRX.XCAP.ODD_D_BUF.t10 VSS 0.27182f
C578 XRX.XCAP.ODD_D_BUF.t9 VSS 0.27182f
C579 XRX.XCAP.ODD_D_BUF.n0 VSS 1.02634f
C580 XRX.XCAP.ODD_D_BUF.n1 VSS 0.52004f
C581 XRX.XCAP.ODD_D_BUF.t8 VSS 1.33971f
C582 XRX.XCAP.ODD_D_BUF.n2 VSS 1.10721f
C583 XRX.XCAP.ODD_D_BUF.t7 VSS 1.34772f
C584 XRX.XCAP.ODD_D_BUF.t6 VSS 0.27182f
C585 XRX.XCAP.ODD_D_BUF.t5 VSS 0.27182f
C586 XRX.XCAP.ODD_D_BUF.n3 VSS 1.03396f
C587 XRX.XCAP.ODD_D_BUF.n4 VSS 0.56834f
C588 XRX.XCAP.ODD_D_BUF.t4 VSS 0.27182f
C589 XRX.XCAP.ODD_D_BUF.t3 VSS 0.27182f
C590 XRX.XCAP.ODD_D_BUF.n5 VSS 1.03396f
C591 XRX.XCAP.ODD_D_BUF.n6 VSS 0.2383f
C592 XRX.XCAP.ODD_D_BUF.t0 VSS 1.34772f
C593 XRX.XCAP.ODD_D_BUF.t2 VSS 0.27182f
C594 XRX.XCAP.ODD_D_BUF.t1 VSS 0.27182f
C595 XRX.XCAP.ODD_D_BUF.n7 VSS 1.03396f
C596 XRX.XCAP.ODD_D_BUF.n8 VSS 0.50995f
C597 XRX.XCAP.ODD_D_BUF.n9 VSS 0.11678f
C598 XRX.XCAP.ODD_D_BUF.n10 VSS 2.49974f
C599 XRX.XCAP.ODD_D_BUF.n11 VSS 0.33019f
C600 XRX.XCAP.ODD_D_BUF.n12 VSS 0.16321f
C601 XRX.XCAP.ODD_D_BUF.n13 VSS 0.17494f
C602 XRX.XCAP.ODD_D_BUF.n14 VSS 0.17494f
C603 XRX.XCAP.ODD_D_BUF.n15 VSS 0.16534f
C604 XRX.XCAP.ODD_D_BUF.n16 VSS 1.68886f
C605 XRX.XCAP.ODD_D_BUF.n17 VSS 3.87043f
C606 XRX.XCAP.ODD_D_BUF.n18 VSS 0.33019f
C607 XRX.XCAP.ODD_D_BUF.n19 VSS 0.16321f
C608 XRX.XCAP.ODD_D_BUF.n20 VSS 0.17494f
C609 XRX.XCAP.ODD_D_BUF.n21 VSS 0.17494f
C610 XRX.XCAP.ODD_D_BUF.n22 VSS 0.16534f
C611 XRX.XCAP.ODD_D_BUF.n23 VSS 2.03803f
C612 XRX.XCAP.ODD_D_BUF.n24 VSS 3.5691f
C613 XRX.XCAP.E_QBI.n0 VSS 0.84803f
C614 XRX.XCAP.E_QBI.n1 VSS 0.44045f
C615 XRX.XCAP.E_QBI.n2 VSS 3.21925f
C616 XRX.XCAP.E_QBI.t9 VSS 1.3223f
C617 XRX.XCAP.E_QBI.t8 VSS 1.31385f
C618 XRX.XCAP.E_QBI.n3 VSS 1.04291f
C619 XRX.XCAP.E_QBI.t11 VSS 1.32006f
C620 XRX.XCAP.E_QBI.t10 VSS 1.31159f
C621 XRX.XCAP.E_QBI.n4 VSS 0.5077f
C622 XRX.XCAP.E_QBI.n5 VSS 1.57463f
C623 XRX.XCAP.E_QBI.t2 VSS 1.33522f
C624 XRX.XCAP.E_QBI.t3 VSS 0.35565f
C625 XRX.XCAP.E_QBI.t4 VSS 0.35565f
C626 XRX.XCAP.E_QBI.n6 VSS 0.9346f
C627 XRX.XCAP.E_QBI.n7 VSS 0.47356f
C628 XRX.XCAP.E_QBI.t5 VSS 1.32683f
C629 XRX.XCAP.E_QBI.n8 VSS 0.51261f
C630 XRX.XCAP.E_QBI.n9 VSS 0.96021f
C631 XRX.XCAP.E_QBI.n10 VSS 1.88012f
C632 XRX.XCAP.E_QBI.t0 VSS 1.33746f
C633 XRX.XCAP.E_QBI.t1 VSS 0.35565f
C634 XRX.XCAP.E_QBI.t6 VSS 0.35565f
C635 XRX.XCAP.E_QBI.n11 VSS 0.94155f
C636 XRX.XCAP.E_QBI.t7 VSS 1.33412f
C637 XRX.XCAP.E_QBI.n12 VSS 2.12356f
C638 XRX.XCAP.E_QBI.n13 VSS 0.42173f
C639 XRX.XCAP.E_QBI.n14 VSS 3.48843f
C640 XRX.XCAP.E_QBI.n15 VSS 0.44926f
C641 XRX.XCAP.E_QBI.n16 VSS 1.3761f
C642 XRX.XCAP.E_QBI.n17 VSS 0.45859f
C643 XRX.XCAP.E_PRST_TAIL.t4 VSS 1.66645f
C644 XRX.XCAP.E_PRST_TAIL.t6 VSS 0.31976f
C645 XRX.XCAP.E_PRST_TAIL.t5 VSS 0.31976f
C646 XRX.XCAP.E_PRST_TAIL.n0 VSS 1.29586f
C647 XRX.XCAP.E_PRST_TAIL.n1 VSS 0.71229f
C648 XRX.XCAP.E_PRST_TAIL.t8 VSS 0.31976f
C649 XRX.XCAP.E_PRST_TAIL.t7 VSS 0.31976f
C650 XRX.XCAP.E_PRST_TAIL.n2 VSS 1.29586f
C651 XRX.XCAP.E_PRST_TAIL.n3 VSS 0.37183f
C652 XRX.XCAP.E_PRST_TAIL.t10 VSS 0.31976f
C653 XRX.XCAP.E_PRST_TAIL.t9 VSS 0.31976f
C654 XRX.XCAP.E_PRST_TAIL.n4 VSS 1.29586f
C655 XRX.XCAP.E_PRST_TAIL.n5 VSS 0.37183f
C656 XRX.XCAP.E_PRST_TAIL.t11 VSS 1.65616f
C657 XRX.XCAP.E_PRST_TAIL.n6 VSS 5.16751f
C658 XRX.XCAP.E_PRST_TAIL.t0 VSS 0.42743f
C659 XRX.XCAP.E_PRST_TAIL.t1 VSS 0.4241f
C660 XRX.XCAP.E_PRST_TAIL.n7 VSS 1.30601f
C661 XRX.XCAP.E_PRST_TAIL.t2 VSS 0.4241f
C662 XRX.XCAP.E_PRST_TAIL.t3 VSS 0.4241f
C663 XRX.XCAP.E_PRST_TAIL.n8 VSS 1.29586f
C664 XRX.XCAP.E_PRST_TAIL.n9 VSS 3.3314f
C665 XRX.XCAP.E_PRST_TAIL.n10 VSS 7.14958f
C666 XRX.XCAP.O_PRST_TAIL.t9 VSS 0.45317f
C667 XRX.XCAP.O_PRST_TAIL.t10 VSS 0.45317f
C668 XRX.XCAP.O_PRST_TAIL.n0 VSS 1.47829f
C669 XRX.XCAP.O_PRST_TAIL.t11 VSS 0.45317f
C670 XRX.XCAP.O_PRST_TAIL.t8 VSS 0.45643f
C671 XRX.XCAP.O_PRST_TAIL.n1 VSS 1.4668f
C672 XRX.XCAP.O_PRST_TAIL.n2 VSS 3.90634f
C673 XRX.XCAP.O_PRST_TAIL.t7 VSS 1.88149f
C674 XRX.XCAP.O_PRST_TAIL.t6 VSS 0.35577f
C675 XRX.XCAP.O_PRST_TAIL.t5 VSS 0.35577f
C676 XRX.XCAP.O_PRST_TAIL.n3 VSS 1.4668f
C677 XRX.XCAP.O_PRST_TAIL.n4 VSS 0.80625f
C678 XRX.XCAP.O_PRST_TAIL.t4 VSS 0.35577f
C679 XRX.XCAP.O_PRST_TAIL.t3 VSS 0.35577f
C680 XRX.XCAP.O_PRST_TAIL.n5 VSS 1.4668f
C681 XRX.XCAP.O_PRST_TAIL.n6 VSS 0.42088f
C682 XRX.XCAP.O_PRST_TAIL.t2 VSS 0.35577f
C683 XRX.XCAP.O_PRST_TAIL.t1 VSS 0.35577f
C684 XRX.XCAP.O_PRST_TAIL.n7 VSS 1.4668f
C685 XRX.XCAP.O_PRST_TAIL.n8 VSS 0.42088f
C686 XRX.XCAP.O_PRST_TAIL.t0 VSS 1.86694f
C687 XRX.XCAP.O_PRST_TAIL.n9 VSS 3.44009f
C688 XRX.XCAP.O_PRST_TAIL.n10 VSS 6.46887f
C689 XRX.XCAP.O_QBI.t6 VSS 1.36529f
C690 XRX.XCAP.O_QBI.t8 VSS 0.3572f
C691 XRX.XCAP.O_QBI.t9 VSS 0.3572f
C692 XRX.XCAP.O_QBI.n0 VSS 0.97004f
C693 XRX.XCAP.O_QBI.t4 VSS 1.36855f
C694 XRX.XCAP.O_QBI.n1 VSS 2.18783f
C695 XRX.XCAP.O_QBI.n2 VSS 0.4345f
C696 XRX.XCAP.O_QBI.n3 VSS 3.47797f
C697 XRX.XCAP.O_QBI.n4 VSS 0.48595f
C698 XRX.XCAP.O_QBI.n5 VSS 1.71164f
C699 XRX.XCAP.O_QBI.t1 VSS 1.35633f
C700 XRX.XCAP.O_QBI.t0 VSS 1.34763f
C701 XRX.XCAP.O_QBI.n6 VSS 1.04242f
C702 XRX.XCAP.O_QBI.t7 VSS 1.36624f
C703 XRX.XCAP.O_QBI.t10 VSS 0.3572f
C704 XRX.XCAP.O_QBI.t11 VSS 0.3572f
C705 XRX.XCAP.O_QBI.n7 VSS 0.96289f
C706 XRX.XCAP.O_QBI.n8 VSS 0.48789f
C707 XRX.XCAP.O_QBI.t5 VSS 1.35778f
C708 XRX.XCAP.O_QBI.n9 VSS 0.57498f
C709 XRX.XCAP.O_QBI.t3 VSS 1.35402f
C710 XRX.XCAP.O_QBI.t2 VSS 1.3453f
C711 XRX.XCAP.O_QBI.n10 VSS 0.52306f
C712 XRX.XCAP.O_QBI.n11 VSS 1.05845f
C713 XRX.XCAP.O_QBI.n12 VSS 1.53829f
C714 XRX.XCAP.O_QBI.n13 VSS 1.50493f
C715 XRX.XCAP.O_QBI.n14 VSS 0.8737f
C716 XRX.XCAP.O_QBI.n15 VSS 0.45378f
C717 XRX.XCAP.O_QBI.n16 VSS 2.72459f
C718 XRX.XCAP.O_QBI.n17 VSS 0.66575f
C719 XRX.XCAP.E_QBBUF.t1 VSS 1.15841f
C720 XRX.XCAP.E_QBBUF.t0 VSS 1.15119f
C721 XRX.XCAP.E_QBBUF.n0 VSS 1.11868f
C722 XRX.XCAP.E_QBBUF.t3 VSS 0.55612f
C723 XRX.XCAP.E_QBBUF.t2 VSS 0.54975f
C724 XRX.XCAP.E_QBBUF.n1 VSS 0.49446f
C725 XRX.XCAP.E_QBBUF.n2 VSS 2.10122f
C726 XRX.XCAP.E_QBBUF.n3 VSS 0.12582f
C727 XRX.XCAP.E_QBBUF.n4 VSS 0.13681f
C728 XRX.XCAP.E_QBBUF.n5 VSS 0.13681f
C729 XRX.XCAP.E_QBBUF.n6 VSS 0.12582f
C730 XRX.XCAP.E_QBBUF.n7 VSS 1.1405f
C731 XRX.XCAP.E_QBBUF.n8 VSS 0.12979f
C732 XRX.XCAP.E_QBBUF.n9 VSS 0.13681f
C733 XRX.XCAP.E_QBBUF.n10 VSS 0.1247f
C734 XRX.XCAP.E_QBBUF.n11 VSS 0.29031f
C735 XRX.XCAP.E_QBBUF.n12 VSS 2.47221f
C736 XRX.XCAP.E_QBBUF.n13 VSS 0.71331f
C737 XRX.XCAP.E_QBUF.t0 VSS 1.10555f
C738 XRX.XCAP.E_QBUF.t1 VSS 1.09867f
C739 XRX.XCAP.E_QBUF.n0 VSS 1.06423f
C740 XRX.XCAP.E_QBUF.t2 VSS 0.53094f
C741 XRX.XCAP.E_QBUF.t3 VSS 0.52489f
C742 XRX.XCAP.E_QBUF.n1 VSS 0.47039f
C743 XRX.XCAP.E_QBUF.n2 VSS 1.92533f
C744 XRX.XCAP.E_QBUF.n3 VSS 0.11969f
C745 XRX.XCAP.E_QBUF.n4 VSS 0.13015f
C746 XRX.XCAP.E_QBUF.n5 VSS 0.13015f
C747 XRX.XCAP.E_QBUF.n6 VSS 0.11969f
C748 XRX.XCAP.E_QBUF.n7 VSS 1.08499f
C749 XRX.XCAP.E_QBUF.n8 VSS 0.12347f
C750 XRX.XCAP.E_QBUF.n9 VSS 0.13015f
C751 XRX.XCAP.E_QBUF.n10 VSS 0.11863f
C752 XRX.XCAP.E_QBUF.n11 VSS 0.27618f
C753 XRX.XCAP.E_QBUF.n12 VSS 2.26498f
C754 XRX.XCAP.E_QBUF.n13 VSS 0.65507f
C755 XRX.XCAP.O_QBUF.n0 VSS 0.12253f
C756 XRX.XCAP.O_QBUF.n1 VSS 0.13323f
C757 XRX.XCAP.O_QBUF.n2 VSS 0.13323f
C758 XRX.XCAP.O_QBUF.n3 VSS 0.12253f
C759 XRX.XCAP.O_QBUF.n4 VSS 1.04857f
C760 XRX.XCAP.O_QBUF.n5 VSS 0.12639f
C761 XRX.XCAP.O_QBUF.n6 VSS 0.13323f
C762 XRX.XCAP.O_QBUF.n7 VSS 0.12143f
C763 XRX.XCAP.O_QBUF.n8 VSS 0.28917f
C764 XRX.XCAP.O_QBUF.n9 VSS 2.53404f
C765 XRX.XCAP.O_QBUF.t0 VSS 1.13276f
C766 XRX.XCAP.O_QBUF.t3 VSS 1.12572f
C767 XRX.XCAP.O_QBUF.n10 VSS 1.08943f
C768 XRX.XCAP.O_QBUF.t1 VSS 0.54407f
C769 XRX.XCAP.O_QBUF.t2 VSS 0.53788f
C770 XRX.XCAP.O_QBUF.n11 VSS 0.48153f
C771 XRX.XCAP.O_QBUF.n12 VSS 1.70254f
C772 XRX.XCAP.O_QBUF.n13 VSS 0.78588f
C773 XRX.XCAP.O_QBBUF.n0 VSS 0.13089f
C774 XRX.XCAP.O_QBBUF.n1 VSS 0.14232f
C775 XRX.XCAP.O_QBBUF.n2 VSS 0.14232f
C776 XRX.XCAP.O_QBBUF.n3 VSS 0.13089f
C777 XRX.XCAP.O_QBBUF.n4 VSS 1.1571f
C778 XRX.XCAP.O_QBBUF.n5 VSS 0.13501f
C779 XRX.XCAP.O_QBBUF.n6 VSS 0.14232f
C780 XRX.XCAP.O_QBBUF.n7 VSS 0.12972f
C781 XRX.XCAP.O_QBBUF.n8 VSS 0.30396f
C782 XRX.XCAP.O_QBBUF.n9 VSS 2.67488f
C783 XRX.XCAP.O_QBBUF.t1 VSS 1.19746f
C784 XRX.XCAP.O_QBBUF.t0 VSS 1.18994f
C785 XRX.XCAP.O_QBBUF.n10 VSS 1.16376f
C786 XRX.XCAP.O_QBBUF.t3 VSS 0.57442f
C787 XRX.XCAP.O_QBBUF.t2 VSS 0.5678f
C788 XRX.XCAP.O_QBBUF.n11 VSS 0.51438f
C789 XRX.XCAP.O_QBBUF.n12 VSS 1.90408f
C790 XRX.XCAP.O_QBBUF.n13 VSS 0.85474f
C791 XRX.XCAP.E_QI.n0 VSS 0.63088f
C792 XRX.XCAP.E_QI.n1 VSS 0.45242f
C793 XRX.XCAP.E_QI.n2 VSS 2.36456f
C794 XRX.XCAP.E_QI.t7 VSS 1.34407f
C795 XRX.XCAP.E_QI.t6 VSS 0.33566f
C796 XRX.XCAP.E_QI.t5 VSS 0.33566f
C797 XRX.XCAP.E_QI.n3 VSS 0.96761f
C798 XRX.XCAP.E_QI.n4 VSS 0.47722f
C799 XRX.XCAP.E_QI.t4 VSS 1.33603f
C800 XRX.XCAP.E_QI.n5 VSS 0.57123f
C801 XRX.XCAP.E_QI.t2 VSS 1.35007f
C802 XRX.XCAP.E_QI.t3 VSS 1.34138f
C803 XRX.XCAP.E_QI.n6 VSS 0.51712f
C804 XRX.XCAP.E_QI.n7 VSS 2.04798f
C805 XRX.XCAP.E_QI.t0 VSS 1.34776f
C806 XRX.XCAP.E_QI.t1 VSS 1.33906f
C807 XRX.XCAP.E_QI.n8 VSS 0.52175f
C808 XRX.XCAP.E_QI.n9 VSS 1.16581f
C809 XRX.XCAP.E_QI.t11 VSS 1.34176f
C810 XRX.XCAP.E_QI.t10 VSS 0.33566f
C811 XRX.XCAP.E_QI.t9 VSS 0.33566f
C812 XRX.XCAP.E_QI.n10 VSS 0.96048f
C813 XRX.XCAP.E_QI.n11 VSS 0.48667f
C814 XRX.XCAP.E_QI.t8 VSS 1.33372f
C815 XRX.XCAP.E_QI.n12 VSS 0.8327f
C816 XRX.XCAP.E_QI.n13 VSS 1.61519f
C817 XRX.XCAP.E_QI.n14 VSS 1.78228f
C818 XRX.XCAP.E_QI.n15 VSS 0.81587f
C819 XRX.XCAP.E_QI.n16 VSS 0.40427f
C820 XRX.XCAP.E_QI.n17 VSS 2.92071f
C821 XRX.XCAP.E_QI.n18 VSS 1.02098f
C822 XRX.XCAP.EVEN_DB_BUF.n0 VSS 0.2892f
C823 XRX.XCAP.EVEN_DB_BUF.n1 VSS 0.14295f
C824 XRX.XCAP.EVEN_DB_BUF.n2 VSS 0.15323f
C825 XRX.XCAP.EVEN_DB_BUF.n3 VSS 0.15323f
C826 XRX.XCAP.EVEN_DB_BUF.n4 VSS 0.14482f
C827 XRX.XCAP.EVEN_DB_BUF.n5 VSS 0.28527f
C828 XRX.XCAP.EVEN_DB_BUF.n6 VSS 0.2892f
C829 XRX.XCAP.EVEN_DB_BUF.n7 VSS 0.14295f
C830 XRX.XCAP.EVEN_DB_BUF.n8 VSS 0.15323f
C831 XRX.XCAP.EVEN_DB_BUF.n9 VSS 0.15323f
C832 XRX.XCAP.EVEN_DB_BUF.n10 VSS 0.14482f
C833 XRX.XCAP.EVEN_DB_BUF.n11 VSS 1.62031f
C834 XRX.XCAP.EVEN_DB_BUF.n12 VSS 4.02148f
C835 XRX.XCAP.EVEN_DB_BUF.t11 VSS 1.18827f
C836 XRX.XCAP.EVEN_DB_BUF.t10 VSS 0.2479f
C837 XRX.XCAP.EVEN_DB_BUF.t9 VSS 0.2479f
C838 XRX.XCAP.EVEN_DB_BUF.n13 VSS 0.89894f
C839 XRX.XCAP.EVEN_DB_BUF.n14 VSS 0.45549f
C840 XRX.XCAP.EVEN_DB_BUF.t8 VSS 1.18342f
C841 XRX.XCAP.EVEN_DB_BUF.n15 VSS 0.96977f
C842 XRX.XCAP.EVEN_DB_BUF.t7 VSS 1.19043f
C843 XRX.XCAP.EVEN_DB_BUF.t6 VSS 0.2479f
C844 XRX.XCAP.EVEN_DB_BUF.t5 VSS 0.2479f
C845 XRX.XCAP.EVEN_DB_BUF.n16 VSS 0.90562f
C846 XRX.XCAP.EVEN_DB_BUF.n17 VSS 0.49779f
C847 XRX.XCAP.EVEN_DB_BUF.t4 VSS 0.2479f
C848 XRX.XCAP.EVEN_DB_BUF.t3 VSS 0.2479f
C849 XRX.XCAP.EVEN_DB_BUF.n18 VSS 0.90562f
C850 XRX.XCAP.EVEN_DB_BUF.n19 VSS 0.20872f
C851 XRX.XCAP.EVEN_DB_BUF.t0 VSS 1.19043f
C852 XRX.XCAP.EVEN_DB_BUF.t2 VSS 0.2479f
C853 XRX.XCAP.EVEN_DB_BUF.t1 VSS 0.2479f
C854 XRX.XCAP.EVEN_DB_BUF.n20 VSS 0.90562f
C855 XRX.XCAP.EVEN_DB_BUF.n21 VSS 0.44665f
C856 XRX.XCAP.EVEN_DB_BUF.n22 VSS 0.10228f
C857 XRX.XCAP.EVEN_DB_BUF.n23 VSS 1.79576f
C858 XRX.XCAP.EVEN_DB_BUF.n24 VSS 0.71125f
C859 XRX.XCAP.ODD_DB_BUF.t11 VSS 1.19917f
C860 XRX.XCAP.ODD_DB_BUF.t10 VSS 0.2446f
C861 XRX.XCAP.ODD_DB_BUF.t9 VSS 0.2446f
C862 XRX.XCAP.ODD_DB_BUF.n0 VSS 0.91264f
C863 XRX.XCAP.ODD_DB_BUF.n1 VSS 0.46243f
C864 XRX.XCAP.ODD_DB_BUF.t8 VSS 1.19424f
C865 XRX.XCAP.ODD_DB_BUF.n2 VSS 0.98455f
C866 XRX.XCAP.ODD_DB_BUF.t7 VSS 1.20136f
C867 XRX.XCAP.ODD_DB_BUF.t6 VSS 0.2446f
C868 XRX.XCAP.ODD_DB_BUF.t5 VSS 0.2446f
C869 XRX.XCAP.ODD_DB_BUF.n3 VSS 0.91942f
C870 XRX.XCAP.ODD_DB_BUF.n4 VSS 0.50537f
C871 XRX.XCAP.ODD_DB_BUF.t4 VSS 0.2446f
C872 XRX.XCAP.ODD_DB_BUF.t3 VSS 0.2446f
C873 XRX.XCAP.ODD_DB_BUF.n5 VSS 0.91942f
C874 XRX.XCAP.ODD_DB_BUF.n6 VSS 0.2119f
C875 XRX.XCAP.ODD_DB_BUF.t0 VSS 1.20136f
C876 XRX.XCAP.ODD_DB_BUF.t2 VSS 0.2446f
C877 XRX.XCAP.ODD_DB_BUF.t1 VSS 0.2446f
C878 XRX.XCAP.ODD_DB_BUF.n7 VSS 0.91942f
C879 XRX.XCAP.ODD_DB_BUF.n8 VSS 0.45345f
C880 XRX.XCAP.ODD_DB_BUF.n9 VSS 0.10384f
C881 XRX.XCAP.ODD_DB_BUF.n10 VSS 2.21745f
C882 XRX.XCAP.ODD_DB_BUF.n11 VSS 0.29361f
C883 XRX.XCAP.ODD_DB_BUF.n12 VSS 0.14513f
C884 XRX.XCAP.ODD_DB_BUF.n13 VSS 0.15556f
C885 XRX.XCAP.ODD_DB_BUF.n14 VSS 0.15556f
C886 XRX.XCAP.ODD_DB_BUF.n15 VSS 0.14702f
C887 XRX.XCAP.ODD_DB_BUF.n16 VSS 0.26874f
C888 XRX.XCAP.ODD_DB_BUF.n17 VSS 0.29361f
C889 XRX.XCAP.ODD_DB_BUF.n18 VSS 0.14513f
C890 XRX.XCAP.ODD_DB_BUF.n19 VSS 0.15556f
C891 XRX.XCAP.ODD_DB_BUF.n20 VSS 0.15556f
C892 XRX.XCAP.ODD_DB_BUF.n21 VSS 0.14702f
C893 XRX.XCAP.ODD_DB_BUF.n22 VSS 1.73534f
C894 XRX.XCAP.ODD_DB_BUF.n23 VSS 3.87678f
C895 XRX.XCAP.ODD_DB_BUF.n24 VSS 0.93564f
C896 XRX.XCAP.O_QI.n0 VSS 0.81035f
C897 XRX.XCAP.O_QI.n1 VSS 0.40154f
C898 XRX.XCAP.O_QI.n2 VSS 3.28197f
C899 XRX.XCAP.O_QI.t7 VSS 1.33831f
C900 XRX.XCAP.O_QI.t8 VSS 0.33666f
C901 XRX.XCAP.O_QI.t4 VSS 0.33666f
C902 XRX.XCAP.O_QI.n3 VSS 0.96107f
C903 XRX.XCAP.O_QI.n4 VSS 0.474f
C904 XRX.XCAP.O_QI.t5 VSS 1.33027f
C905 XRX.XCAP.O_QI.n5 VSS 0.56737f
C906 XRX.XCAP.O_QI.t11 VSS 1.34677f
C907 XRX.XCAP.O_QI.t0 VSS 1.33815f
C908 XRX.XCAP.O_QI.n6 VSS 0.51362f
C909 XRX.XCAP.O_QI.n7 VSS 2.03413f
C910 XRX.XCAP.O_QI.t10 VSS 1.34448f
C911 XRX.XCAP.O_QI.t9 VSS 1.33584f
C912 XRX.XCAP.O_QI.n8 VSS 0.51822f
C913 XRX.XCAP.O_QI.n9 VSS 1.04296f
C914 XRX.XCAP.O_QI.t1 VSS 1.33602f
C915 XRX.XCAP.O_QI.t2 VSS 0.33666f
C916 XRX.XCAP.O_QI.t3 VSS 0.33666f
C917 XRX.XCAP.O_QI.n10 VSS 0.95398f
C918 XRX.XCAP.O_QI.n11 VSS 0.48338f
C919 XRX.XCAP.O_QI.t6 VSS 1.32798f
C920 XRX.XCAP.O_QI.n12 VSS 0.9167f
C921 XRX.XCAP.O_QI.n13 VSS 1.6296f
C922 XRX.XCAP.O_QI.n14 VSS 2.1671f
C923 XRX.XCAP.O_QI.n15 VSS 0.58411f
C924 XRX.XCAP.O_QI.n16 VSS 0.46929f
C925 XRX.XCAP.O_QI.n17 VSS 2.17206f
C926 XRX.XCAP.O_QI.n18 VSS 0.4681f
C927 XRX.XCAP.E_PSET_TAIL.t11 VSS 1.97714f
C928 XRX.XCAP.E_PSET_TAIL.t10 VSS 0.36826f
C929 XRX.XCAP.E_PSET_TAIL.t9 VSS 0.36826f
C930 XRX.XCAP.E_PSET_TAIL.n0 VSS 1.54688f
C931 XRX.XCAP.E_PSET_TAIL.n1 VSS 0.85027f
C932 XRX.XCAP.E_PSET_TAIL.t8 VSS 0.36826f
C933 XRX.XCAP.E_PSET_TAIL.t7 VSS 0.36826f
C934 XRX.XCAP.E_PSET_TAIL.n2 VSS 1.54688f
C935 XRX.XCAP.E_PSET_TAIL.n3 VSS 0.44386f
C936 XRX.XCAP.E_PSET_TAIL.t6 VSS 0.36826f
C937 XRX.XCAP.E_PSET_TAIL.t5 VSS 0.36826f
C938 XRX.XCAP.E_PSET_TAIL.n4 VSS 1.54688f
C939 XRX.XCAP.E_PSET_TAIL.n5 VSS 0.44386f
C940 XRX.XCAP.E_PSET_TAIL.t4 VSS 1.96193f
C941 XRX.XCAP.E_PSET_TAIL.n6 VSS 2.2193f
C942 XRX.XCAP.E_PSET_TAIL.t0 VSS 0.45042f
C943 XRX.XCAP.E_PSET_TAIL.t1 VSS 0.44756f
C944 XRX.XCAP.E_PSET_TAIL.n7 VSS 1.55899f
C945 XRX.XCAP.E_PSET_TAIL.t2 VSS 0.44756f
C946 XRX.XCAP.E_PSET_TAIL.t3 VSS 0.44756f
C947 XRX.XCAP.E_PSET_TAIL.n8 VSS 1.54688f
C948 XRX.XCAP.E_PSET_TAIL.n9 VSS 2.2126f
C949 XRX.XCAP.E_PSET_TAIL.n10 VSS 3.81367f
C950 XRX.XCAP.O_PSET_TAIL.t0 VSS 0.43217f
C951 XRX.XCAP.O_PSET_TAIL.t1 VSS 0.43217f
C952 XRX.XCAP.O_PSET_TAIL.n0 VSS 1.46688f
C953 XRX.XCAP.O_PSET_TAIL.t2 VSS 0.43507f
C954 XRX.XCAP.O_PSET_TAIL.t3 VSS 0.43217f
C955 XRX.XCAP.O_PSET_TAIL.n1 VSS 1.45549f
C956 XRX.XCAP.O_PSET_TAIL.n2 VSS 2.74646f
C957 XRX.XCAP.O_PSET_TAIL.t11 VSS 1.86755f
C958 XRX.XCAP.O_PSET_TAIL.t10 VSS 0.35358f
C959 XRX.XCAP.O_PSET_TAIL.t9 VSS 0.35358f
C960 XRX.XCAP.O_PSET_TAIL.n3 VSS 1.45549f
C961 XRX.XCAP.O_PSET_TAIL.n4 VSS 0.80004f
C962 XRX.XCAP.O_PSET_TAIL.t8 VSS 0.35358f
C963 XRX.XCAP.O_PSET_TAIL.t7 VSS 0.35358f
C964 XRX.XCAP.O_PSET_TAIL.n5 VSS 1.45549f
C965 XRX.XCAP.O_PSET_TAIL.n6 VSS 0.41764f
C966 XRX.XCAP.O_PSET_TAIL.t6 VSS 0.35358f
C967 XRX.XCAP.O_PSET_TAIL.t5 VSS 0.35358f
C968 XRX.XCAP.O_PSET_TAIL.n7 VSS 1.45549f
C969 XRX.XCAP.O_PSET_TAIL.n8 VSS 0.41764f
C970 XRX.XCAP.O_PSET_TAIL.t4 VSS 1.8531f
C971 XRX.XCAP.O_PSET_TAIL.n9 VSS 1.58693f
C972 XRX.XCAP.O_PSET_TAIL.n10 VSS 4.05229f
C973 XRX.XCAP.E_SET_TAIL.t2 VSS 0.3085f
C974 XRX.XCAP.E_SET_TAIL.t3 VSS 0.3085f
C975 XRX.XCAP.E_SET_TAIL.n0 VSS 0.69793f
C976 XRX.XCAP.E_SET_TAIL.t0 VSS 0.31184f
C977 XRX.XCAP.E_SET_TAIL.t1 VSS 0.3085f
C978 XRX.XCAP.E_SET_TAIL.n1 VSS 0.69236f
C979 XRX.XCAP.E_SET_TAIL.n2 VSS 0.55269f
C980 XRX.XCAP.E_SET_TAIL.t11 VSS 0.89666f
C981 XRX.XCAP.E_SET_TAIL.t10 VSS 0.17274f
C982 XRX.XCAP.E_SET_TAIL.t9 VSS 0.17274f
C983 XRX.XCAP.E_SET_TAIL.n3 VSS 0.69236f
C984 XRX.XCAP.E_SET_TAIL.n4 VSS 0.3902f
C985 XRX.XCAP.E_SET_TAIL.t8 VSS 0.17274f
C986 XRX.XCAP.E_SET_TAIL.t7 VSS 0.17274f
C987 XRX.XCAP.E_SET_TAIL.n5 VSS 0.69236f
C988 XRX.XCAP.E_SET_TAIL.n6 VSS 0.20528f
C989 XRX.XCAP.E_SET_TAIL.t4 VSS 0.89666f
C990 XRX.XCAP.E_SET_TAIL.t6 VSS 0.17274f
C991 XRX.XCAP.E_SET_TAIL.t5 VSS 0.17274f
C992 XRX.XCAP.E_SET_TAIL.n7 VSS 0.69236f
C993 XRX.XCAP.E_SET_TAIL.n8 VSS 0.59761f
C994 XRX.XCAP.E_SET_TAIL.n9 VSS 1.04754f
C995 XRX.XCAP.O_SET_TAIL.t7 VSS 0.87379f
C996 XRX.XCAP.O_SET_TAIL.t6 VSS 0.17065f
C997 XRX.XCAP.O_SET_TAIL.t5 VSS 0.17065f
C998 XRX.XCAP.O_SET_TAIL.n0 VSS 0.67242f
C999 XRX.XCAP.O_SET_TAIL.n1 VSS 0.37897f
C1000 XRX.XCAP.O_SET_TAIL.t4 VSS 0.17065f
C1001 XRX.XCAP.O_SET_TAIL.t3 VSS 0.17065f
C1002 XRX.XCAP.O_SET_TAIL.n2 VSS 0.67242f
C1003 XRX.XCAP.O_SET_TAIL.n3 VSS 0.19937f
C1004 XRX.XCAP.O_SET_TAIL.t0 VSS 0.87379f
C1005 XRX.XCAP.O_SET_TAIL.t2 VSS 0.17065f
C1006 XRX.XCAP.O_SET_TAIL.t1 VSS 0.17065f
C1007 XRX.XCAP.O_SET_TAIL.n4 VSS 0.67242f
C1008 XRX.XCAP.O_SET_TAIL.n5 VSS 0.55941f
C1009 XRX.XCAP.O_SET_TAIL.t11 VSS 0.30067f
C1010 XRX.XCAP.O_SET_TAIL.t8 VSS 0.30067f
C1011 XRX.XCAP.O_SET_TAIL.n6 VSS 0.67784f
C1012 XRX.XCAP.O_SET_TAIL.t9 VSS 0.30393f
C1013 XRX.XCAP.O_SET_TAIL.t10 VSS 0.30067f
C1014 XRX.XCAP.O_SET_TAIL.n7 VSS 0.67242f
C1015 XRX.XCAP.O_SET_TAIL.n8 VSS 0.49654f
C1016 XRX.XCAP.O_SET_TAIL.n9 VSS 0.70815f
C1017 XRX.XCAP.E_RST_TAIL.t11 VSS 0.69824f
C1018 XRX.XCAP.E_RST_TAIL.t10 VSS 0.14169f
C1019 XRX.XCAP.E_RST_TAIL.t9 VSS 0.14169f
C1020 XRX.XCAP.E_RST_TAIL.n0 VSS 0.53282f
C1021 XRX.XCAP.E_RST_TAIL.n1 VSS 0.30029f
C1022 XRX.XCAP.E_RST_TAIL.t8 VSS 0.14169f
C1023 XRX.XCAP.E_RST_TAIL.t7 VSS 0.14169f
C1024 XRX.XCAP.E_RST_TAIL.n2 VSS 0.53282f
C1025 XRX.XCAP.E_RST_TAIL.n3 VSS 0.15798f
C1026 XRX.XCAP.E_RST_TAIL.t6 VSS 0.14169f
C1027 XRX.XCAP.E_RST_TAIL.t5 VSS 0.14169f
C1028 XRX.XCAP.E_RST_TAIL.n4 VSS 0.53282f
C1029 XRX.XCAP.E_RST_TAIL.n5 VSS 0.12767f
C1030 XRX.XCAP.E_RST_TAIL.t4 VSS 0.6961f
C1031 XRX.XCAP.E_RST_TAIL.n6 VSS 0.39529f
C1032 XRX.XCAP.E_RST_TAIL.t3 VSS 0.25242f
C1033 XRX.XCAP.E_RST_TAIL.t0 VSS 0.25242f
C1034 XRX.XCAP.E_RST_TAIL.n7 VSS 0.53711f
C1035 XRX.XCAP.E_RST_TAIL.t1 VSS 0.25528f
C1036 XRX.XCAP.E_RST_TAIL.t2 VSS 0.25242f
C1037 XRX.XCAP.E_RST_TAIL.n8 VSS 0.53282f
C1038 XRX.XCAP.E_RST_TAIL.n9 VSS 0.74854f
C1039 XRX.XCAP.E_RST_TAIL.n10 VSS 0.8009f
C1040 XRX.XCAP.O_RST_TAIL.t10 VSS 0.26572f
C1041 XRX.XCAP.O_RST_TAIL.t11 VSS 0.26572f
C1042 XRX.XCAP.O_RST_TAIL.n0 VSS 0.59423f
C1043 XRX.XCAP.O_RST_TAIL.t8 VSS 0.26861f
C1044 XRX.XCAP.O_RST_TAIL.t9 VSS 0.26572f
C1045 XRX.XCAP.O_RST_TAIL.n1 VSS 0.58949f
C1046 XRX.XCAP.O_RST_TAIL.n2 VSS 1.09562f
C1047 XRX.XCAP.O_RST_TAIL.t7 VSS 0.77026f
C1048 XRX.XCAP.O_RST_TAIL.t6 VSS 0.15451f
C1049 XRX.XCAP.O_RST_TAIL.t5 VSS 0.15451f
C1050 XRX.XCAP.O_RST_TAIL.n3 VSS 0.58949f
C1051 XRX.XCAP.O_RST_TAIL.n4 VSS 0.33223f
C1052 XRX.XCAP.O_RST_TAIL.t4 VSS 0.15451f
C1053 XRX.XCAP.O_RST_TAIL.t3 VSS 0.15451f
C1054 XRX.XCAP.O_RST_TAIL.n5 VSS 0.58949f
C1055 XRX.XCAP.O_RST_TAIL.n6 VSS 0.17478f
C1056 XRX.XCAP.O_RST_TAIL.t2 VSS 0.15451f
C1057 XRX.XCAP.O_RST_TAIL.t1 VSS 0.15451f
C1058 XRX.XCAP.O_RST_TAIL.n7 VSS 0.58949f
C1059 XRX.XCAP.O_RST_TAIL.n8 VSS 0.14125f
C1060 XRX.XCAP.O_RST_TAIL.t0 VSS 0.76784f
C1061 XRX.XCAP.O_RST_TAIL.n9 VSS 0.46717f
C1062 XRX.XCAP.O_RST_TAIL.n10 VSS 1.44128f
C1063 XRX.XFRONT.XFE_E.VREGN.t15 VSS 2.05441f
C1064 XRX.XFRONT.XFE_E.VREGN.t14 VSS 0.43778f
C1065 XRX.XFRONT.XFE_E.VREGN.t13 VSS 0.43778f
C1066 XRX.XFRONT.XFE_E.VREGN.n0 VSS 1.55201f
C1067 XRX.XFRONT.XFE_E.VREGN.n1 VSS 0.85309f
C1068 XRX.XFRONT.XFE_E.VREGN.t12 VSS 0.43778f
C1069 XRX.XFRONT.XFE_E.VREGN.t11 VSS 0.43778f
C1070 XRX.XFRONT.XFE_E.VREGN.n2 VSS 1.55201f
C1071 XRX.XFRONT.XFE_E.VREGN.n3 VSS 0.35769f
C1072 XRX.XFRONT.XFE_E.VREGN.t8 VSS 2.05072f
C1073 XRX.XFRONT.XFE_E.VREGN.t10 VSS 0.43778f
C1074 XRX.XFRONT.XFE_E.VREGN.t9 VSS 0.43778f
C1075 XRX.XFRONT.XFE_E.VREGN.n4 VSS 1.55201f
C1076 XRX.XFRONT.XFE_E.VREGN.n5 VSS 0.76545f
C1077 XRX.XFRONT.XFE_E.VREGN.n6 VSS 0.70781f
C1078 XRX.XFRONT.XFE_E.VREGN.t7 VSS 0.44748f
C1079 XRX.XFRONT.XFE_E.VREGN.t6 VSS 0.44357f
C1080 XRX.XFRONT.XFE_E.VREGN.n7 VSS 1.56416f
C1081 XRX.XFRONT.XFE_E.VREGN.t5 VSS 0.44357f
C1082 XRX.XFRONT.XFE_E.VREGN.t4 VSS 0.44357f
C1083 XRX.XFRONT.XFE_E.VREGN.n8 VSS 1.55201f
C1084 XRX.XFRONT.XFE_E.VREGN.n9 VSS 0.78649f
C1085 XRX.XFRONT.XFE_E.VREGN.t3 VSS 0.44357f
C1086 XRX.XFRONT.XFE_E.VREGN.t2 VSS 0.44357f
C1087 XRX.XFRONT.XFE_E.VREGN.n10 VSS 1.55201f
C1088 XRX.XFRONT.XFE_E.VREGN.n11 VSS 0.44533f
C1089 XRX.XFRONT.XFE_E.VREGN.t1 VSS 0.44357f
C1090 XRX.XFRONT.XFE_E.VREGN.t0 VSS 0.44357f
C1091 XRX.XFRONT.XFE_E.VREGN.n12 VSS 1.55201f
C1092 XRX.XFRONT.XFE_E.VREGN.n13 VSS 1.47521f
C1093 XRX.XFRONT.XFE_E.VREGN.n14 VSS 1.97789f
C1094 XRX.XFRONT.XFE_E.SB.n0 VSS 0.13155f
C1095 XRX.XFRONT.XFE_E.SB.n1 VSS 0.08021f
C1096 XRX.XFRONT.XFE_E.SB.n2 VSS 0.2771f
C1097 XRX.XFRONT.XFE_E.SB.n3 VSS 0.14681f
C1098 XRX.XFRONT.XFE_E.SB.n4 VSS 0.2771f
C1099 XRX.XFRONT.XFE_E.SB.n5 VSS 0.13697f
C1100 XRX.XFRONT.XFE_E.SB.n6 VSS 0.14681f
C1101 XRX.XFRONT.XFE_E.SB.n7 VSS 0.40649f
C1102 XRX.XFRONT.XFE_E.SB.n8 VSS 0.20576f
C1103 XRX.XFRONT.XFE_E.SB.n9 VSS 0.19077f
C1104 XRX.XFRONT.XFE_E.SB.n10 VSS 0.14681f
C1105 XRX.XFRONT.XFE_E.SB.n11 VSS 0.14681f
C1106 XRX.XFRONT.XFE_E.SB.n12 VSS 0.19077f
C1107 XRX.XFRONT.XFE_E.SB.n13 VSS 0.13697f
C1108 XRX.XFRONT.XFE_E.SB.n14 VSS 0.40649f
C1109 XRX.XFRONT.XFE_E.SB.n15 VSS 0.20576f
C1110 XRX.XFRONT.XFE_E.SB.n16 VSS 0.14681f
C1111 XRX.XFRONT.XFE_E.SB.n17 VSS 0.14681f
C1112 XRX.XFRONT.XFE_E.SB.n18 VSS 0.08021f
C1113 XRX.XFRONT.XFE_E.SB.n19 VSS 0.06663f
C1114 XRX.XFRONT.XFE_E.SB.n20 VSS 0.97831f
C1115 XRX.XFRONT.XFE_E.SB.t1 VSS 1.23317f
C1116 XRX.XFRONT.XFE_E.SB.t0 VSS 1.22543f
C1117 XRX.XFRONT.XFE_E.SB.n21 VSS 1.08915f
C1118 XRX.XFRONT.XFE_E.SB.t5 VSS 1.12965f
C1119 XRX.XFRONT.XFE_E.SB.t4 VSS 1.13745f
C1120 XRX.XFRONT.XFE_E.SB.n22 VSS 0.46789f
C1121 XRX.XFRONT.XFE_E.SB.n23 VSS 1.54724f
C1122 XRX.XFRONT.XFE_E.SB.t6 VSS 2.07955f
C1123 XRX.XFRONT.XFE_E.SB.t3 VSS 0.33146f
C1124 XRX.XFRONT.XFE_E.SB.t2 VSS 0.33143f
C1125 XRX.XFRONT.XFE_E.SB.n24 VSS 1.07064f
C1126 XRX.XFRONT.XFE_E.SB.n25 VSS 2.8859f
C1127 XRX.XFRONT.XFE_E.SB.n26 VSS 2.7955f
C1128 XRX.XFRONT.XFE_E.SA.t0 VSS 1.28668f
C1129 XRX.XFRONT.XFE_E.SA.t1 VSS 1.27847f
C1130 XRX.XFRONT.XFE_E.SA.n0 VSS 1.33857f
C1131 XRX.XFRONT.XFE_E.SA.t6 VSS 1.16514f
C1132 XRX.XFRONT.XFE_E.SA.t5 VSS 1.17333f
C1133 XRX.XFRONT.XFE_E.SA.n1 VSS 0.49128f
C1134 XRX.XFRONT.XFE_E.SA.n2 VSS 1.53905f
C1135 XRX.XFRONT.XFE_E.SA.n3 VSS 0.13813f
C1136 XRX.XFRONT.XFE_E.SA.n4 VSS 0.08422f
C1137 XRX.XFRONT.XFE_E.SA.n5 VSS 0.29096f
C1138 XRX.XFRONT.XFE_E.SA.n6 VSS 0.15416f
C1139 XRX.XFRONT.XFE_E.SA.n7 VSS 0.29096f
C1140 XRX.XFRONT.XFE_E.SA.n8 VSS 0.14381f
C1141 XRX.XFRONT.XFE_E.SA.n9 VSS 0.15416f
C1142 XRX.XFRONT.XFE_E.SA.n10 VSS 0.42682f
C1143 XRX.XFRONT.XFE_E.SA.n11 VSS 0.21605f
C1144 XRX.XFRONT.XFE_E.SA.n12 VSS 0.20031f
C1145 XRX.XFRONT.XFE_E.SA.n13 VSS 0.15416f
C1146 XRX.XFRONT.XFE_E.SA.n14 VSS 0.15416f
C1147 XRX.XFRONT.XFE_E.SA.n15 VSS 0.20031f
C1148 XRX.XFRONT.XFE_E.SA.n16 VSS 0.14381f
C1149 XRX.XFRONT.XFE_E.SA.n17 VSS 0.42682f
C1150 XRX.XFRONT.XFE_E.SA.n18 VSS 0.21605f
C1151 XRX.XFRONT.XFE_E.SA.n19 VSS 0.15416f
C1152 XRX.XFRONT.XFE_E.SA.n20 VSS 0.15416f
C1153 XRX.XFRONT.XFE_E.SA.n21 VSS 0.08422f
C1154 XRX.XFRONT.XFE_E.SA.n22 VSS 0.06997f
C1155 XRX.XFRONT.XFE_E.SA.n23 VSS 1.7301f
C1156 XRX.XFRONT.XFE_E.SA.t4 VSS 2.08471f
C1157 XRX.XFRONT.XFE_E.SA.t3 VSS 1.28664f
C1158 XRX.XFRONT.XFE_E.SA.t2 VSS 1.27851f
C1159 XRX.XFRONT.XFE_E.SA.n24 VSS 0.7353f
C1160 XRX.XFRONT.XFE_E.SA.n25 VSS 2.83246f
C1161 XRX.XFRONT.XFE_E.SA.n26 VSS 3.35641f
C1162 XRX.XFRONT.XFE_E.VREGP.t9 VSS 0.46595f
C1163 XRX.XFRONT.XFE_E.VREGP.t8 VSS 0.46998f
C1164 XRX.XFRONT.XFE_E.VREGP.n0 VSS 1.65721f
C1165 XRX.XFRONT.XFE_E.VREGP.t11 VSS 0.46595f
C1166 XRX.XFRONT.XFE_E.VREGP.t10 VSS 0.46595f
C1167 XRX.XFRONT.XFE_E.VREGP.n1 VSS 1.64434f
C1168 XRX.XFRONT.XFE_E.VREGP.n2 VSS 0.83328f
C1169 XRX.XFRONT.XFE_E.VREGP.t13 VSS 0.46595f
C1170 XRX.XFRONT.XFE_E.VREGP.t12 VSS 0.46595f
C1171 XRX.XFRONT.XFE_E.VREGP.n3 VSS 1.64434f
C1172 XRX.XFRONT.XFE_E.VREGP.n4 VSS 0.47183f
C1173 XRX.XFRONT.XFE_E.VREGP.t15 VSS 0.46998f
C1174 XRX.XFRONT.XFE_E.VREGP.t14 VSS 0.46595f
C1175 XRX.XFRONT.XFE_E.VREGP.n5 VSS 1.64434f
C1176 XRX.XFRONT.XFE_E.VREGP.n6 VSS 2.2363f
C1177 XRX.XFRONT.XFE_E.VREGP.t7 VSS 2.1682f
C1178 XRX.XFRONT.XFE_E.VREGP.t6 VSS 0.45561f
C1179 XRX.XFRONT.XFE_E.VREGP.t5 VSS 0.45561f
C1180 XRX.XFRONT.XFE_E.VREGP.n7 VSS 1.64434f
C1181 XRX.XFRONT.XFE_E.VREGP.n8 VSS 0.81098f
C1182 XRX.XFRONT.XFE_E.VREGP.t0 VSS 2.1682f
C1183 XRX.XFRONT.XFE_E.VREGP.t2 VSS 0.45561f
C1184 XRX.XFRONT.XFE_E.VREGP.t1 VSS 0.45561f
C1185 XRX.XFRONT.XFE_E.VREGP.n9 VSS 1.64434f
C1186 XRX.XFRONT.XFE_E.VREGP.n10 VSS 0.90384f
C1187 XRX.XFRONT.XFE_E.VREGP.t4 VSS 0.45561f
C1188 XRX.XFRONT.XFE_E.VREGP.t3 VSS 0.45561f
C1189 XRX.XFRONT.XFE_E.VREGP.n11 VSS 1.64434f
C1190 XRX.XFRONT.XFE_E.VREGP.n12 VSS 0.37897f
C1191 XRX.XFRONT.XFE_E.VREGP.n13 VSS 1.21829f
C1192 XRX.XFRONT.XFE_O.VREGP.t7 VSS 2.1682f
C1193 XRX.XFRONT.XFE_O.VREGP.t6 VSS 0.45561f
C1194 XRX.XFRONT.XFE_O.VREGP.t5 VSS 0.45561f
C1195 XRX.XFRONT.XFE_O.VREGP.n0 VSS 1.64434f
C1196 XRX.XFRONT.XFE_O.VREGP.n1 VSS 0.90384f
C1197 XRX.XFRONT.XFE_O.VREGP.t4 VSS 0.45561f
C1198 XRX.XFRONT.XFE_O.VREGP.t3 VSS 0.45561f
C1199 XRX.XFRONT.XFE_O.VREGP.n2 VSS 1.64434f
C1200 XRX.XFRONT.XFE_O.VREGP.n3 VSS 0.37897f
C1201 XRX.XFRONT.XFE_O.VREGP.t0 VSS 2.1682f
C1202 XRX.XFRONT.XFE_O.VREGP.t2 VSS 0.45561f
C1203 XRX.XFRONT.XFE_O.VREGP.t1 VSS 0.45561f
C1204 XRX.XFRONT.XFE_O.VREGP.n4 VSS 1.64434f
C1205 XRX.XFRONT.XFE_O.VREGP.n5 VSS 0.81098f
C1206 XRX.XFRONT.XFE_O.VREGP.n6 VSS 1.22138f
C1207 XRX.XFRONT.XFE_O.VREGP.t15 VSS 0.46998f
C1208 XRX.XFRONT.XFE_O.VREGP.t14 VSS 0.46595f
C1209 XRX.XFRONT.XFE_O.VREGP.n7 VSS 1.65721f
C1210 XRX.XFRONT.XFE_O.VREGP.t13 VSS 0.46595f
C1211 XRX.XFRONT.XFE_O.VREGP.t12 VSS 0.46595f
C1212 XRX.XFRONT.XFE_O.VREGP.n8 VSS 1.64434f
C1213 XRX.XFRONT.XFE_O.VREGP.n9 VSS 0.83328f
C1214 XRX.XFRONT.XFE_O.VREGP.t11 VSS 0.46595f
C1215 XRX.XFRONT.XFE_O.VREGP.t10 VSS 0.46595f
C1216 XRX.XFRONT.XFE_O.VREGP.n10 VSS 1.64434f
C1217 XRX.XFRONT.XFE_O.VREGP.n11 VSS 0.47183f
C1218 XRX.XFRONT.XFE_O.VREGP.t9 VSS 0.46595f
C1219 XRX.XFRONT.XFE_O.VREGP.t8 VSS 0.46998f
C1220 XRX.XFRONT.XFE_O.VREGP.n12 VSS 1.64434f
C1221 XRX.XFRONT.XFE_O.VREGP.n13 VSS 2.23447f
C1222 XRX.XFRONT.XFE_O.VREGP.n14 VSS 1.85505f
C1223 XRX.XFRONT.XFE_O.SA.n0 VSS 0.13813f
C1224 XRX.XFRONT.XFE_O.SA.n1 VSS 0.08422f
C1225 XRX.XFRONT.XFE_O.SA.n2 VSS 0.29096f
C1226 XRX.XFRONT.XFE_O.SA.n3 VSS 0.15416f
C1227 XRX.XFRONT.XFE_O.SA.n4 VSS 0.29096f
C1228 XRX.XFRONT.XFE_O.SA.n5 VSS 0.14381f
C1229 XRX.XFRONT.XFE_O.SA.n6 VSS 0.15416f
C1230 XRX.XFRONT.XFE_O.SA.n7 VSS 0.42682f
C1231 XRX.XFRONT.XFE_O.SA.n8 VSS 0.21605f
C1232 XRX.XFRONT.XFE_O.SA.n9 VSS 0.20031f
C1233 XRX.XFRONT.XFE_O.SA.n10 VSS 0.15416f
C1234 XRX.XFRONT.XFE_O.SA.n11 VSS 0.15416f
C1235 XRX.XFRONT.XFE_O.SA.n12 VSS 0.20031f
C1236 XRX.XFRONT.XFE_O.SA.n13 VSS 0.14381f
C1237 XRX.XFRONT.XFE_O.SA.n14 VSS 0.42682f
C1238 XRX.XFRONT.XFE_O.SA.n15 VSS 0.21605f
C1239 XRX.XFRONT.XFE_O.SA.n16 VSS 0.15416f
C1240 XRX.XFRONT.XFE_O.SA.n17 VSS 0.15416f
C1241 XRX.XFRONT.XFE_O.SA.n18 VSS 0.08422f
C1242 XRX.XFRONT.XFE_O.SA.n19 VSS 0.06997f
C1243 XRX.XFRONT.XFE_O.SA.n20 VSS 1.7301f
C1244 XRX.XFRONT.XFE_O.SA.t0 VSS 2.0847f
C1245 XRX.XFRONT.XFE_O.SA.t4 VSS 1.28664f
C1246 XRX.XFRONT.XFE_O.SA.t3 VSS 1.27851f
C1247 XRX.XFRONT.XFE_O.SA.n21 VSS 0.7353f
C1248 XRX.XFRONT.XFE_O.SA.n22 VSS 2.83246f
C1249 XRX.XFRONT.XFE_O.SA.n23 VSS 3.3642f
C1250 XRX.XFRONT.XFE_O.SA.t2 VSS 1.28668f
C1251 XRX.XFRONT.XFE_O.SA.t1 VSS 1.27847f
C1252 XRX.XFRONT.XFE_O.SA.n24 VSS 1.33857f
C1253 XRX.XFRONT.XFE_O.SA.t6 VSS 1.17349f
C1254 XRX.XFRONT.XFE_O.SA.t5 VSS 1.1653f
C1255 XRX.XFRONT.XFE_O.SA.n25 VSS 0.49128f
C1256 XRX.XFRONT.XFE_O.SA.n26 VSS 1.53799f
C1257 XRX.XFRONT.XFE_O.SA.n27 VSS 0.73959f
C1258 XRX.XFRONT.XFE_O.SB.t1 VSS 1.23317f
C1259 XRX.XFRONT.XFE_O.SB.t2 VSS 1.22543f
C1260 XRX.XFRONT.XFE_O.SB.n0 VSS 1.08915f
C1261 XRX.XFRONT.XFE_O.SB.t6 VSS 1.13739f
C1262 XRX.XFRONT.XFE_O.SB.t5 VSS 1.12959f
C1263 XRX.XFRONT.XFE_O.SB.n1 VSS 0.46789f
C1264 XRX.XFRONT.XFE_O.SB.n2 VSS 1.54724f
C1265 XRX.XFRONT.XFE_O.SB.t0 VSS 2.07955f
C1266 XRX.XFRONT.XFE_O.SB.t3 VSS 0.33143f
C1267 XRX.XFRONT.XFE_O.SB.t4 VSS 0.33146f
C1268 XRX.XFRONT.XFE_O.SB.n3 VSS 1.07064f
C1269 XRX.XFRONT.XFE_O.SB.n4 VSS 2.8859f
C1270 XRX.XFRONT.XFE_O.SB.n5 VSS 2.80291f
C1271 XRX.XFRONT.XFE_O.SB.n6 VSS 0.13155f
C1272 XRX.XFRONT.XFE_O.SB.n7 VSS 0.08021f
C1273 XRX.XFRONT.XFE_O.SB.n8 VSS 0.2771f
C1274 XRX.XFRONT.XFE_O.SB.n9 VSS 0.14681f
C1275 XRX.XFRONT.XFE_O.SB.n10 VSS 0.2771f
C1276 XRX.XFRONT.XFE_O.SB.n11 VSS 0.13697f
C1277 XRX.XFRONT.XFE_O.SB.n12 VSS 0.14681f
C1278 XRX.XFRONT.XFE_O.SB.n13 VSS 0.40649f
C1279 XRX.XFRONT.XFE_O.SB.n14 VSS 0.20576f
C1280 XRX.XFRONT.XFE_O.SB.n15 VSS 0.19077f
C1281 XRX.XFRONT.XFE_O.SB.n16 VSS 0.14681f
C1282 XRX.XFRONT.XFE_O.SB.n17 VSS 0.14681f
C1283 XRX.XFRONT.XFE_O.SB.n18 VSS 0.19077f
C1284 XRX.XFRONT.XFE_O.SB.n19 VSS 0.13697f
C1285 XRX.XFRONT.XFE_O.SB.n20 VSS 0.40649f
C1286 XRX.XFRONT.XFE_O.SB.n21 VSS 0.20576f
C1287 XRX.XFRONT.XFE_O.SB.n22 VSS 0.14681f
C1288 XRX.XFRONT.XFE_O.SB.n23 VSS 0.14681f
C1289 XRX.XFRONT.XFE_O.SB.n24 VSS 0.08021f
C1290 XRX.XFRONT.XFE_O.SB.n25 VSS 0.06663f
C1291 XRX.XFRONT.XFE_O.SB.n26 VSS 0.97774f
C1292 XRX.XFRONT.XFE_O.SB.n27 VSS 1.27166f
C1293 XRX.XFRONT.XFE_O.VREGN.t7 VSS 2.05072f
C1294 XRX.XFRONT.XFE_O.VREGN.t6 VSS 0.43778f
C1295 XRX.XFRONT.XFE_O.VREGN.t5 VSS 0.43778f
C1296 XRX.XFRONT.XFE_O.VREGN.n0 VSS 1.55201f
C1297 XRX.XFRONT.XFE_O.VREGN.n1 VSS 0.76545f
C1298 XRX.XFRONT.XFE_O.VREGN.t0 VSS 2.05441f
C1299 XRX.XFRONT.XFE_O.VREGN.t2 VSS 0.43778f
C1300 XRX.XFRONT.XFE_O.VREGN.t1 VSS 0.43778f
C1301 XRX.XFRONT.XFE_O.VREGN.n2 VSS 1.55201f
C1302 XRX.XFRONT.XFE_O.VREGN.n3 VSS 0.85309f
C1303 XRX.XFRONT.XFE_O.VREGN.t4 VSS 0.43778f
C1304 XRX.XFRONT.XFE_O.VREGN.t3 VSS 0.43778f
C1305 XRX.XFRONT.XFE_O.VREGN.n4 VSS 1.55201f
C1306 XRX.XFRONT.XFE_O.VREGN.n5 VSS 0.35769f
C1307 XRX.XFRONT.XFE_O.VREGN.n6 VSS 0.70781f
C1308 XRX.XFRONT.XFE_O.VREGN.t9 VSS 0.44357f
C1309 XRX.XFRONT.XFE_O.VREGN.t8 VSS 0.44748f
C1310 XRX.XFRONT.XFE_O.VREGN.n7 VSS 1.56416f
C1311 XRX.XFRONT.XFE_O.VREGN.t11 VSS 0.44357f
C1312 XRX.XFRONT.XFE_O.VREGN.t10 VSS 0.44357f
C1313 XRX.XFRONT.XFE_O.VREGN.n8 VSS 1.55201f
C1314 XRX.XFRONT.XFE_O.VREGN.n9 VSS 0.78649f
C1315 XRX.XFRONT.XFE_O.VREGN.t13 VSS 0.44357f
C1316 XRX.XFRONT.XFE_O.VREGN.t12 VSS 0.44357f
C1317 XRX.XFRONT.XFE_O.VREGN.n10 VSS 1.55201f
C1318 XRX.XFRONT.XFE_O.VREGN.n11 VSS 0.44533f
C1319 XRX.XFRONT.XFE_O.VREGN.t15 VSS 0.44357f
C1320 XRX.XFRONT.XFE_O.VREGN.t14 VSS 0.44357f
C1321 XRX.XFRONT.XFE_O.VREGN.n12 VSS 1.55201f
C1322 XRX.XFRONT.XFE_O.VREGN.n13 VSS 1.47521f
C1323 XRX.XFRONT.XFE_O.VREGN.n14 VSS 1.97789f
C1324 XRX.XFRONT.XFE_E.XN.n0 VSS 0.18804f
C1325 XRX.XFRONT.XFE_E.XN.n1 VSS 0.38313f
C1326 XRX.XFRONT.XFE_E.XN.n2 VSS 0.13428f
C1327 XRX.XFRONT.XFE_E.XN.n3 VSS 0.2094f
C1328 XRX.XFRONT.XFE_E.XN.n4 VSS 0.19535f
C1329 XRX.XFRONT.XFE_E.XN.n5 VSS 0.57977f
C1330 XRX.XFRONT.XFE_E.XN.n6 VSS 0.28137f
C1331 XRX.XFRONT.XFE_E.XN.n7 VSS 0.2094f
C1332 XRX.XFRONT.XFE_E.XN.n8 VSS 0.2094f
C1333 XRX.XFRONT.XFE_E.XN.n9 VSS 0.2639f
C1334 XRX.XFRONT.XFE_E.XN.n10 VSS 0.29196f
C1335 XRX.XFRONT.XFE_E.XN.n11 VSS 0.29347f
C1336 XRX.XFRONT.XFE_E.XN.n12 VSS 0.57977f
C1337 XRX.XFRONT.XFE_E.XN.n13 VSS 0.19535f
C1338 XRX.XFRONT.XFE_E.XN.n14 VSS 0.39522f
C1339 XRX.XFRONT.XFE_E.XN.n15 VSS 0.2094f
C1340 XRX.XFRONT.XFE_E.XN.n16 VSS 0.2094f
C1341 XRX.XFRONT.XFE_E.XN.n17 VSS 0.2094f
C1342 XRX.XFRONT.XFE_E.XN.n18 VSS 0.10621f
C1343 XRX.XFRONT.XFE_E.XN.n19 VSS 0.09546f
C1344 XRX.XFRONT.XFE_E.XN.n20 VSS 1.55365f
C1345 XRX.XFRONT.XFE_E.XN.n21 VSS 0.19535f
C1346 XRX.XFRONT.XFE_E.XN.n22 VSS 0.2094f
C1347 XRX.XFRONT.XFE_E.XN.n23 VSS 0.1979f
C1348 XRX.XFRONT.XFE_E.XN.n24 VSS 1.02723f
C1349 XRX.XFRONT.XFE_E.XN.n25 VSS 1.79502f
C1350 XRX.XFRONT.XFE_E.XN.n26 VSS 0.10621f
C1351 XRX.XFRONT.XFE_E.XN.n27 VSS 0.2094f
C1352 XRX.XFRONT.XFE_E.XN.n28 VSS 0.39522f
C1353 XRX.XFRONT.XFE_E.XN.n29 VSS 0.19535f
C1354 XRX.XFRONT.XFE_E.XN.n30 VSS 0.2094f
C1355 XRX.XFRONT.XFE_E.XN.n31 VSS 0.2094f
C1356 XRX.XFRONT.XFE_E.XN.n32 VSS 0.2094f
C1357 XRX.XFRONT.XFE_E.XN.n33 VSS 0.13579f
C1358 XRX.XFRONT.XFE_E.XN.n34 VSS 0.13579f
C1359 XRX.XFRONT.XFE_E.XN.n35 VSS 0.13428f
C1360 XRX.XFRONT.XFE_E.XN.n36 VSS 0.2094f
C1361 XRX.XFRONT.XFE_E.XN.n37 VSS 0.2094f
C1362 XRX.XFRONT.XFE_E.XN.n38 VSS 0.19839f
C1363 XRX.XFRONT.XFE_E.XN.n39 VSS 0.25314f
C1364 XRX.XFRONT.XFE_E.XN.t16 VSS 1.6344f
C1365 XRX.XFRONT.XFE_E.XN.t34 VSS 0.34825f
C1366 XRX.XFRONT.XFE_E.XN.t4 VSS 0.34825f
C1367 XRX.XFRONT.XFE_E.XN.n40 VSS 1.22847f
C1368 XRX.XFRONT.XFE_E.XN.n41 VSS 0.62246f
C1369 XRX.XFRONT.XFE_E.XN.t1 VSS 1.6344f
C1370 XRX.XFRONT.XFE_E.XN.t3 VSS 0.34825f
C1371 XRX.XFRONT.XFE_E.XN.t2 VSS 0.34825f
C1372 XRX.XFRONT.XFE_E.XN.n42 VSS 1.22847f
C1373 XRX.XFRONT.XFE_E.XN.n43 VSS 0.69235f
C1374 XRX.XFRONT.XFE_E.XN.t0 VSS 0.34825f
C1375 XRX.XFRONT.XFE_E.XN.t33 VSS 0.34825f
C1376 XRX.XFRONT.XFE_E.XN.n44 VSS 1.22847f
C1377 XRX.XFRONT.XFE_E.XN.n45 VSS 0.29435f
C1378 XRX.XFRONT.XFE_E.XN.n46 VSS 0.21105f
C1379 XRX.XFRONT.XFE_E.XN.n47 VSS 0.39522f
C1380 XRX.XFRONT.XFE_E.XN.n48 VSS 0.19535f
C1381 XRX.XFRONT.XFE_E.XN.n49 VSS 0.2094f
C1382 XRX.XFRONT.XFE_E.XN.n50 VSS 0.2094f
C1383 XRX.XFRONT.XFE_E.XN.n51 VSS 0.1979f
C1384 XRX.XFRONT.XFE_E.XN.n52 VSS 0.3206f
C1385 XRX.XFRONT.XFE_E.XN.n53 VSS 0.71021f
C1386 XRX.XFRONT.XFE_E.XN.n54 VSS 0.87854f
C1387 XRX.XFRONT.XFE_E.XN.t15 VSS 1.67287f
C1388 XRX.XFRONT.XFE_E.XN.t6 VSS 0.38283f
C1389 XRX.XFRONT.XFE_E.XN.t5 VSS 0.38283f
C1390 XRX.XFRONT.XFE_E.XN.n55 VSS 1.2376f
C1391 XRX.XFRONT.XFE_E.XN.n56 VSS 0.68027f
C1392 XRX.XFRONT.XFE_E.XN.t10 VSS 0.38283f
C1393 XRX.XFRONT.XFE_E.XN.t9 VSS 0.38283f
C1394 XRX.XFRONT.XFE_E.XN.n57 VSS 1.2376f
C1395 XRX.XFRONT.XFE_E.XN.n58 VSS 0.33764f
C1396 XRX.XFRONT.XFE_E.XN.t8 VSS 1.66897f
C1397 XRX.XFRONT.XFE_E.XN.t11 VSS 0.38283f
C1398 XRX.XFRONT.XFE_E.XN.t7 VSS 0.38283f
C1399 XRX.XFRONT.XFE_E.XN.n59 VSS 1.2376f
C1400 XRX.XFRONT.XFE_E.XN.n60 VSS 0.55796f
C1401 XRX.XFRONT.XFE_E.XN.n61 VSS 0.69915f
C1402 XRX.XFRONT.XFE_E.XN.t13 VSS 0.4361f
C1403 XRX.XFRONT.XFE_E.XN.t12 VSS 0.4361f
C1404 XRX.XFRONT.XFE_E.XN.n62 VSS 1.23836f
C1405 XRX.XFRONT.XFE_E.XN.t14 VSS 1.71194f
C1406 XRX.XFRONT.XFE_E.XN.n63 VSS 0.969f
C1407 XRX.XFRONT.XFE_E.XN.n64 VSS 1.90694f
C1408 XRX.XFRONT.XFE_E.XN.n65 VSS 1.38561f
C1409 XRX.XFRONT.XFE_E.XN.t24 VSS 1.62732f
C1410 XRX.XFRONT.XFE_E.XN.t17 VSS 1.6301f
C1411 XRX.XFRONT.XFE_E.XN.t19 VSS 0.34118f
C1412 XRX.XFRONT.XFE_E.XN.t18 VSS 0.34118f
C1413 XRX.XFRONT.XFE_E.XN.n66 VSS 1.2376f
C1414 XRX.XFRONT.XFE_E.XN.n67 VSS 0.68027f
C1415 XRX.XFRONT.XFE_E.XN.t21 VSS 0.34118f
C1416 XRX.XFRONT.XFE_E.XN.t20 VSS 0.34118f
C1417 XRX.XFRONT.XFE_E.XN.n68 VSS 1.2376f
C1418 XRX.XFRONT.XFE_E.XN.n69 VSS 0.35512f
C1419 XRX.XFRONT.XFE_E.XN.t23 VSS 0.34118f
C1420 XRX.XFRONT.XFE_E.XN.t22 VSS 0.34118f
C1421 XRX.XFRONT.XFE_E.XN.n70 VSS 1.2376f
C1422 XRX.XFRONT.XFE_E.XN.n71 VSS 1.93393f
C1423 XRX.XFRONT.XFE_E.XN.n72 VSS 2.19485f
C1424 XRX.XFRONT.XFE_E.XN.t32 VSS 0.34118f
C1425 XRX.XFRONT.XFE_E.XN.t31 VSS 0.34118f
C1426 XRX.XFRONT.XFE_E.XN.n73 VSS 1.24729f
C1427 XRX.XFRONT.XFE_E.XN.t30 VSS 0.34118f
C1428 XRX.XFRONT.XFE_E.XN.t29 VSS 0.34118f
C1429 XRX.XFRONT.XFE_E.XN.n74 VSS 1.2376f
C1430 XRX.XFRONT.XFE_E.XN.n75 VSS 0.62716f
C1431 XRX.XFRONT.XFE_E.XN.t28 VSS 0.34118f
C1432 XRX.XFRONT.XFE_E.XN.t27 VSS 0.34118f
C1433 XRX.XFRONT.XFE_E.XN.n76 VSS 1.2376f
C1434 XRX.XFRONT.XFE_E.XN.n77 VSS 0.28523f
C1435 XRX.XFRONT.XFE_E.XN.t26 VSS 0.34118f
C1436 XRX.XFRONT.XFE_E.XN.t25 VSS 0.34396f
C1437 XRX.XFRONT.XFE_E.XN.n78 VSS 1.2413f
C1438 XRX.XFRONT.XFE_E.XN.n79 VSS 1.39559f
C1439 XRX.XFRONT.XFE_E.XN.n80 VSS 2.5705f
C1440 XRX.XFRONT.XFE_E.XP.n0 VSS 0.13162f
C1441 XRX.XFRONT.XFE_E.XP.n1 VSS 0.13162f
C1442 XRX.XFRONT.XFE_E.XP.n2 VSS 0.13162f
C1443 XRX.XFRONT.XFE_E.XP.n3 VSS 0.13162f
C1444 XRX.XFRONT.XFE_E.XP.n4 VSS 0.38311f
C1445 XRX.XFRONT.XFE_E.XP.n5 VSS 0.18936f
C1446 XRX.XFRONT.XFE_E.XP.n6 VSS 0.20298f
C1447 XRX.XFRONT.XFE_E.XP.n7 VSS 0.20298f
C1448 XRX.XFRONT.XFE_E.XP.n8 VSS 0.20298f
C1449 XRX.XFRONT.XFE_E.XP.n9 VSS 0.20298f
C1450 XRX.XFRONT.XFE_E.XP.n10 VSS 0.20298f
C1451 XRX.XFRONT.XFE_E.XP.n11 VSS 0.20298f
C1452 XRX.XFRONT.XFE_E.XP.n12 VSS 0.19184f
C1453 XRX.XFRONT.XFE_E.XP.n13 VSS 0.36751f
C1454 XRX.XFRONT.XFE_E.XP.t1 VSS 1.5824f
C1455 XRX.XFRONT.XFE_E.XP.t0 VSS 0.33573f
C1456 XRX.XFRONT.XFE_E.XP.t29 VSS 0.33573f
C1457 XRX.XFRONT.XFE_E.XP.n14 VSS 1.19081f
C1458 XRX.XFRONT.XFE_E.XP.n15 VSS 0.60338f
C1459 XRX.XFRONT.XFE_E.XP.t5 VSS 1.5824f
C1460 XRX.XFRONT.XFE_E.XP.t30 VSS 0.33573f
C1461 XRX.XFRONT.XFE_E.XP.t3 VSS 0.33573f
C1462 XRX.XFRONT.XFE_E.XP.n16 VSS 1.19081f
C1463 XRX.XFRONT.XFE_E.XP.n17 VSS 0.67112f
C1464 XRX.XFRONT.XFE_E.XP.t2 VSS 0.33573f
C1465 XRX.XFRONT.XFE_E.XP.t4 VSS 0.33573f
C1466 XRX.XFRONT.XFE_E.XP.n18 VSS 1.19081f
C1467 XRX.XFRONT.XFE_E.XP.n19 VSS 0.28533f
C1468 XRX.XFRONT.XFE_E.XP.n20 VSS 0.20458f
C1469 XRX.XFRONT.XFE_E.XP.n21 VSS 0.38311f
C1470 XRX.XFRONT.XFE_E.XP.n22 VSS 0.18936f
C1471 XRX.XFRONT.XFE_E.XP.n23 VSS 0.20298f
C1472 XRX.XFRONT.XFE_E.XP.n24 VSS 0.20298f
C1473 XRX.XFRONT.XFE_E.XP.n25 VSS 0.19184f
C1474 XRX.XFRONT.XFE_E.XP.n26 VSS 0.51601f
C1475 XRX.XFRONT.XFE_E.XP.n27 VSS 0.65345f
C1476 XRX.XFRONT.XFE_E.XP.n28 VSS 0.71994f
C1477 XRX.XFRONT.XFE_E.XP.n29 VSS 0.75743f
C1478 XRX.XFRONT.XFE_E.XP.n30 VSS 0.13162f
C1479 XRX.XFRONT.XFE_E.XP.n31 VSS 0.13162f
C1480 XRX.XFRONT.XFE_E.XP.n32 VSS 0.13162f
C1481 XRX.XFRONT.XFE_E.XP.n33 VSS 0.13162f
C1482 XRX.XFRONT.XFE_E.XP.n34 VSS 0.38311f
C1483 XRX.XFRONT.XFE_E.XP.n35 VSS 0.28447f
C1484 XRX.XFRONT.XFE_E.XP.n36 VSS 0.28447f
C1485 XRX.XFRONT.XFE_E.XP.n37 VSS 0.28447f
C1486 XRX.XFRONT.XFE_E.XP.n38 VSS 0.28447f
C1487 XRX.XFRONT.XFE_E.XP.n39 VSS 0.28447f
C1488 XRX.XFRONT.XFE_E.XP.n40 VSS 0.562f
C1489 XRX.XFRONT.XFE_E.XP.n41 VSS 0.18936f
C1490 XRX.XFRONT.XFE_E.XP.n42 VSS 0.20298f
C1491 XRX.XFRONT.XFE_E.XP.n43 VSS 0.20298f
C1492 XRX.XFRONT.XFE_E.XP.n44 VSS 0.20298f
C1493 XRX.XFRONT.XFE_E.XP.n45 VSS 0.20298f
C1494 XRX.XFRONT.XFE_E.XP.n46 VSS 0.20298f
C1495 XRX.XFRONT.XFE_E.XP.n47 VSS 0.20298f
C1496 XRX.XFRONT.XFE_E.XP.n48 VSS 0.19184f
C1497 XRX.XFRONT.XFE_E.XP.n49 VSS 0.51601f
C1498 XRX.XFRONT.XFE_E.XP.n50 VSS 1.57338f
C1499 XRX.XFRONT.XFE_E.XP.n51 VSS 0.18936f
C1500 XRX.XFRONT.XFE_E.XP.n52 VSS 0.20298f
C1501 XRX.XFRONT.XFE_E.XP.n53 VSS 0.19184f
C1502 XRX.XFRONT.XFE_E.XP.n54 VSS 0.96466f
C1503 XRX.XFRONT.XFE_E.XP.n55 VSS 2.41464f
C1504 XRX.XFRONT.XFE_E.XP.t17 VSS 1.58056f
C1505 XRX.XFRONT.XFE_E.XP.t16 VSS 0.33385f
C1506 XRX.XFRONT.XFE_E.XP.t15 VSS 0.33385f
C1507 XRX.XFRONT.XFE_E.XP.n56 VSS 1.19966f
C1508 XRX.XFRONT.XFE_E.XP.t18 VSS 1.58333f
C1509 XRX.XFRONT.XFE_E.XP.t20 VSS 0.33385f
C1510 XRX.XFRONT.XFE_E.XP.t19 VSS 0.33385f
C1511 XRX.XFRONT.XFE_E.XP.n57 VSS 1.19966f
C1512 XRX.XFRONT.XFE_E.XP.n58 VSS 0.65942f
C1513 XRX.XFRONT.XFE_E.XP.t22 VSS 0.33385f
C1514 XRX.XFRONT.XFE_E.XP.t21 VSS 0.33385f
C1515 XRX.XFRONT.XFE_E.XP.n59 VSS 1.19966f
C1516 XRX.XFRONT.XFE_E.XP.n60 VSS 0.34423f
C1517 XRX.XFRONT.XFE_E.XP.n61 VSS 1.91833f
C1518 XRX.XFRONT.XFE_E.XP.n62 VSS 3.62399f
C1519 XRX.XFRONT.XFE_E.XP.t14 VSS 1.58333f
C1520 XRX.XFRONT.XFE_E.XP.t13 VSS 0.33385f
C1521 XRX.XFRONT.XFE_E.XP.t12 VSS 0.33385f
C1522 XRX.XFRONT.XFE_E.XP.n63 VSS 1.19966f
C1523 XRX.XFRONT.XFE_E.XP.n64 VSS 0.65942f
C1524 XRX.XFRONT.XFE_E.XP.t11 VSS 0.33385f
C1525 XRX.XFRONT.XFE_E.XP.t10 VSS 0.33385f
C1526 XRX.XFRONT.XFE_E.XP.n65 VSS 1.19966f
C1527 XRX.XFRONT.XFE_E.XP.n66 VSS 0.34423f
C1528 XRX.XFRONT.XFE_E.XP.t7 VSS 1.58056f
C1529 XRX.XFRONT.XFE_E.XP.t9 VSS 0.33385f
C1530 XRX.XFRONT.XFE_E.XP.t8 VSS 0.33385f
C1531 XRX.XFRONT.XFE_E.XP.n67 VSS 1.19966f
C1532 XRX.XFRONT.XFE_E.XP.n68 VSS 1.91833f
C1533 XRX.XFRONT.XFE_E.XP.n69 VSS 2.33527f
C1534 XRX.XFRONT.XFE_E.XP.t32 VSS 1.63078f
C1535 XRX.XFRONT.XFE_E.XP.t34 VSS 0.38004f
C1536 XRX.XFRONT.XFE_E.XP.t31 VSS 0.38004f
C1537 XRX.XFRONT.XFE_E.XP.n70 VSS 1.19966f
C1538 XRX.XFRONT.XFE_E.XP.n71 VSS 0.65942f
C1539 XRX.XFRONT.XFE_E.XP.t26 VSS 0.38004f
C1540 XRX.XFRONT.XFE_E.XP.t33 VSS 0.38004f
C1541 XRX.XFRONT.XFE_E.XP.n72 VSS 1.19966f
C1542 XRX.XFRONT.XFE_E.XP.n73 VSS 0.34423f
C1543 XRX.XFRONT.XFE_E.XP.t24 VSS 0.38004f
C1544 XRX.XFRONT.XFE_E.XP.t25 VSS 0.38004f
C1545 XRX.XFRONT.XFE_E.XP.n74 VSS 1.19966f
C1546 XRX.XFRONT.XFE_E.XP.n75 VSS 0.34423f
C1547 XRX.XFRONT.XFE_E.XP.t23 VSS 1.62002f
C1548 XRX.XFRONT.XFE_E.XP.n76 VSS 1.13469f
C1549 XRX.XFRONT.XFE_E.XP.t27 VSS 0.435f
C1550 XRX.XFRONT.XFE_E.XP.t28 VSS 0.435f
C1551 XRX.XFRONT.XFE_E.XP.n77 VSS 1.2004f
C1552 XRX.XFRONT.XFE_E.XP.t6 VSS 1.67197f
C1553 XRX.XFRONT.XFE_E.XP.n78 VSS 0.90508f
C1554 XRX.XFRONT.XFE_E.XP.n79 VSS 1.85329f
C1555 XRX.XFRONT.XFE_E.XP.n80 VSS 1.03535f
C1556 XRX.XFRONT.XFE_O.XP.n0 VSS 0.75743f
C1557 XRX.XFRONT.XFE_O.XP.n1 VSS 0.13162f
C1558 XRX.XFRONT.XFE_O.XP.n2 VSS 0.20298f
C1559 XRX.XFRONT.XFE_O.XP.n3 VSS 0.28447f
C1560 XRX.XFRONT.XFE_O.XP.n4 VSS 0.20298f
C1561 XRX.XFRONT.XFE_O.XP.n5 VSS 0.13162f
C1562 XRX.XFRONT.XFE_O.XP.n6 VSS 0.18936f
C1563 XRX.XFRONT.XFE_O.XP.n7 VSS 0.20298f
C1564 XRX.XFRONT.XFE_O.XP.n8 VSS 0.562f
C1565 XRX.XFRONT.XFE_O.XP.n9 VSS 0.28447f
C1566 XRX.XFRONT.XFE_O.XP.n10 VSS 0.20298f
C1567 XRX.XFRONT.XFE_O.XP.n11 VSS 0.38311f
C1568 XRX.XFRONT.XFE_O.XP.n12 VSS 0.13162f
C1569 XRX.XFRONT.XFE_O.XP.n13 VSS 0.13162f
C1570 XRX.XFRONT.XFE_O.XP.n14 VSS 0.20298f
C1571 XRX.XFRONT.XFE_O.XP.n15 VSS 0.28447f
C1572 XRX.XFRONT.XFE_O.XP.n16 VSS 0.28447f
C1573 XRX.XFRONT.XFE_O.XP.n17 VSS 0.28447f
C1574 XRX.XFRONT.XFE_O.XP.n18 VSS 0.20298f
C1575 XRX.XFRONT.XFE_O.XP.n19 VSS 0.19184f
C1576 XRX.XFRONT.XFE_O.XP.n20 VSS 0.51601f
C1577 XRX.XFRONT.XFE_O.XP.n21 VSS 1.57338f
C1578 XRX.XFRONT.XFE_O.XP.n22 VSS 0.18936f
C1579 XRX.XFRONT.XFE_O.XP.n23 VSS 0.20298f
C1580 XRX.XFRONT.XFE_O.XP.n24 VSS 0.19184f
C1581 XRX.XFRONT.XFE_O.XP.n25 VSS 0.96466f
C1582 XRX.XFRONT.XFE_O.XP.n26 VSS 2.41464f
C1583 XRX.XFRONT.XFE_O.XP.t22 VSS 1.58333f
C1584 XRX.XFRONT.XFE_O.XP.t21 VSS 0.33385f
C1585 XRX.XFRONT.XFE_O.XP.t20 VSS 0.33385f
C1586 XRX.XFRONT.XFE_O.XP.n27 VSS 1.19966f
C1587 XRX.XFRONT.XFE_O.XP.n28 VSS 0.65942f
C1588 XRX.XFRONT.XFE_O.XP.t19 VSS 0.33385f
C1589 XRX.XFRONT.XFE_O.XP.t18 VSS 0.33385f
C1590 XRX.XFRONT.XFE_O.XP.n29 VSS 1.19966f
C1591 XRX.XFRONT.XFE_O.XP.n30 VSS 0.34423f
C1592 XRX.XFRONT.XFE_O.XP.t17 VSS 0.33385f
C1593 XRX.XFRONT.XFE_O.XP.t16 VSS 0.33385f
C1594 XRX.XFRONT.XFE_O.XP.n31 VSS 1.19966f
C1595 XRX.XFRONT.XFE_O.XP.t15 VSS 1.58056f
C1596 XRX.XFRONT.XFE_O.XP.n32 VSS 1.91833f
C1597 XRX.XFRONT.XFE_O.XP.n33 VSS 3.62399f
C1598 XRX.XFRONT.XFE_O.XP.t14 VSS 1.58056f
C1599 XRX.XFRONT.XFE_O.XP.t7 VSS 1.58333f
C1600 XRX.XFRONT.XFE_O.XP.t9 VSS 0.33385f
C1601 XRX.XFRONT.XFE_O.XP.t8 VSS 0.33385f
C1602 XRX.XFRONT.XFE_O.XP.n34 VSS 1.19966f
C1603 XRX.XFRONT.XFE_O.XP.n35 VSS 0.65942f
C1604 XRX.XFRONT.XFE_O.XP.t11 VSS 0.33385f
C1605 XRX.XFRONT.XFE_O.XP.t10 VSS 0.33385f
C1606 XRX.XFRONT.XFE_O.XP.n36 VSS 1.19966f
C1607 XRX.XFRONT.XFE_O.XP.n37 VSS 0.34423f
C1608 XRX.XFRONT.XFE_O.XP.t13 VSS 0.33385f
C1609 XRX.XFRONT.XFE_O.XP.t12 VSS 0.33385f
C1610 XRX.XFRONT.XFE_O.XP.n38 VSS 1.19966f
C1611 XRX.XFRONT.XFE_O.XP.n39 VSS 1.91833f
C1612 XRX.XFRONT.XFE_O.XP.n40 VSS 2.33527f
C1613 XRX.XFRONT.XFE_O.XP.t23 VSS 1.63078f
C1614 XRX.XFRONT.XFE_O.XP.t24 VSS 0.38004f
C1615 XRX.XFRONT.XFE_O.XP.t27 VSS 0.38004f
C1616 XRX.XFRONT.XFE_O.XP.n41 VSS 1.19966f
C1617 XRX.XFRONT.XFE_O.XP.n42 VSS 0.65942f
C1618 XRX.XFRONT.XFE_O.XP.t26 VSS 0.38004f
C1619 XRX.XFRONT.XFE_O.XP.t33 VSS 0.38004f
C1620 XRX.XFRONT.XFE_O.XP.n43 VSS 1.19966f
C1621 XRX.XFRONT.XFE_O.XP.n44 VSS 0.34423f
C1622 XRX.XFRONT.XFE_O.XP.t32 VSS 0.38004f
C1623 XRX.XFRONT.XFE_O.XP.t31 VSS 0.38004f
C1624 XRX.XFRONT.XFE_O.XP.n45 VSS 1.19966f
C1625 XRX.XFRONT.XFE_O.XP.n46 VSS 0.34423f
C1626 XRX.XFRONT.XFE_O.XP.t25 VSS 1.62002f
C1627 XRX.XFRONT.XFE_O.XP.n47 VSS 1.13469f
C1628 XRX.XFRONT.XFE_O.XP.t30 VSS 0.435f
C1629 XRX.XFRONT.XFE_O.XP.t29 VSS 0.435f
C1630 XRX.XFRONT.XFE_O.XP.n48 VSS 1.2004f
C1631 XRX.XFRONT.XFE_O.XP.t28 VSS 1.67197f
C1632 XRX.XFRONT.XFE_O.XP.n49 VSS 0.90508f
C1633 XRX.XFRONT.XFE_O.XP.n50 VSS 1.85329f
C1634 XRX.XFRONT.XFE_O.XP.n51 VSS 1.0456f
C1635 XRX.XFRONT.XFE_O.XP.n52 VSS 0.13162f
C1636 XRX.XFRONT.XFE_O.XP.n53 VSS 0.20298f
C1637 XRX.XFRONT.XFE_O.XP.n54 VSS 0.38311f
C1638 XRX.XFRONT.XFE_O.XP.n55 VSS 0.18936f
C1639 XRX.XFRONT.XFE_O.XP.n56 VSS 0.20298f
C1640 XRX.XFRONT.XFE_O.XP.n57 VSS 0.20298f
C1641 XRX.XFRONT.XFE_O.XP.n58 VSS 0.20298f
C1642 XRX.XFRONT.XFE_O.XP.n59 VSS 0.13162f
C1643 XRX.XFRONT.XFE_O.XP.n60 VSS 0.13162f
C1644 XRX.XFRONT.XFE_O.XP.n61 VSS 0.13162f
C1645 XRX.XFRONT.XFE_O.XP.n62 VSS 0.20298f
C1646 XRX.XFRONT.XFE_O.XP.n63 VSS 0.20298f
C1647 XRX.XFRONT.XFE_O.XP.n64 VSS 0.19184f
C1648 XRX.XFRONT.XFE_O.XP.n65 VSS 0.36751f
C1649 XRX.XFRONT.XFE_O.XP.t4 VSS 1.5824f
C1650 XRX.XFRONT.XFE_O.XP.t0 VSS 0.33573f
C1651 XRX.XFRONT.XFE_O.XP.t34 VSS 0.33573f
C1652 XRX.XFRONT.XFE_O.XP.n66 VSS 1.19081f
C1653 XRX.XFRONT.XFE_O.XP.n67 VSS 0.67112f
C1654 XRX.XFRONT.XFE_O.XP.t2 VSS 0.33573f
C1655 XRX.XFRONT.XFE_O.XP.t3 VSS 0.33573f
C1656 XRX.XFRONT.XFE_O.XP.n68 VSS 1.19081f
C1657 XRX.XFRONT.XFE_O.XP.n69 VSS 0.28533f
C1658 XRX.XFRONT.XFE_O.XP.t5 VSS 1.5824f
C1659 XRX.XFRONT.XFE_O.XP.t1 VSS 0.33573f
C1660 XRX.XFRONT.XFE_O.XP.t6 VSS 0.33573f
C1661 XRX.XFRONT.XFE_O.XP.n70 VSS 1.19081f
C1662 XRX.XFRONT.XFE_O.XP.n71 VSS 0.60338f
C1663 XRX.XFRONT.XFE_O.XP.n72 VSS 0.20458f
C1664 XRX.XFRONT.XFE_O.XP.n73 VSS 0.38311f
C1665 XRX.XFRONT.XFE_O.XP.n74 VSS 0.18936f
C1666 XRX.XFRONT.XFE_O.XP.n75 VSS 0.20298f
C1667 XRX.XFRONT.XFE_O.XP.n76 VSS 0.20298f
C1668 XRX.XFRONT.XFE_O.XP.n77 VSS 0.19184f
C1669 XRX.XFRONT.XFE_O.XP.n78 VSS 0.51601f
C1670 XRX.XFRONT.XFE_O.XP.n79 VSS 0.65345f
C1671 XRX.XFRONT.XFE_O.XP.n80 VSS 0.71951f
C1672 XRX.XFRONT.XFE_O.XP.n81 VSS 0.43054f
C1673 XRX.XFRONT.XFE_O.XN.n0 VSS 0.19839f
C1674 XRX.XFRONT.XFE_O.XN.n1 VSS 0.13428f
C1675 XRX.XFRONT.XFE_O.XN.n2 VSS 0.13579f
C1676 XRX.XFRONT.XFE_O.XN.n3 VSS 0.13579f
C1677 XRX.XFRONT.XFE_O.XN.n4 VSS 0.39522f
C1678 XRX.XFRONT.XFE_O.XN.n5 VSS 0.19535f
C1679 XRX.XFRONT.XFE_O.XN.n6 VSS 0.2094f
C1680 XRX.XFRONT.XFE_O.XN.n7 VSS 0.2094f
C1681 XRX.XFRONT.XFE_O.XN.n8 VSS 0.2094f
C1682 XRX.XFRONT.XFE_O.XN.n9 VSS 0.2094f
C1683 XRX.XFRONT.XFE_O.XN.n10 VSS 0.2094f
C1684 XRX.XFRONT.XFE_O.XN.n11 VSS 0.2094f
C1685 XRX.XFRONT.XFE_O.XN.n12 VSS 0.10621f
C1686 XRX.XFRONT.XFE_O.XN.n13 VSS 0.25314f
C1687 XRX.XFRONT.XFE_O.XN.t3 VSS 1.6344f
C1688 XRX.XFRONT.XFE_O.XN.t1 VSS 0.34825f
C1689 XRX.XFRONT.XFE_O.XN.t33 VSS 0.34825f
C1690 XRX.XFRONT.XFE_O.XN.n14 VSS 1.22847f
C1691 XRX.XFRONT.XFE_O.XN.n15 VSS 0.69235f
C1692 XRX.XFRONT.XFE_O.XN.t2 VSS 0.34825f
C1693 XRX.XFRONT.XFE_O.XN.t13 VSS 0.34825f
C1694 XRX.XFRONT.XFE_O.XN.n16 VSS 1.22847f
C1695 XRX.XFRONT.XFE_O.XN.n17 VSS 0.29435f
C1696 XRX.XFRONT.XFE_O.XN.t15 VSS 1.6344f
C1697 XRX.XFRONT.XFE_O.XN.t14 VSS 0.34825f
C1698 XRX.XFRONT.XFE_O.XN.t0 VSS 0.34825f
C1699 XRX.XFRONT.XFE_O.XN.n18 VSS 1.22847f
C1700 XRX.XFRONT.XFE_O.XN.n19 VSS 0.62246f
C1701 XRX.XFRONT.XFE_O.XN.n20 VSS 0.21105f
C1702 XRX.XFRONT.XFE_O.XN.n21 VSS 0.39522f
C1703 XRX.XFRONT.XFE_O.XN.n22 VSS 0.19535f
C1704 XRX.XFRONT.XFE_O.XN.n23 VSS 0.2094f
C1705 XRX.XFRONT.XFE_O.XN.n24 VSS 0.2094f
C1706 XRX.XFRONT.XFE_O.XN.n25 VSS 0.1979f
C1707 XRX.XFRONT.XFE_O.XN.n26 VSS 0.3206f
C1708 XRX.XFRONT.XFE_O.XN.n27 VSS 0.71021f
C1709 XRX.XFRONT.XFE_O.XN.n28 VSS 0.87854f
C1710 XRX.XFRONT.XFE_O.XN.t16 VSS 1.66897f
C1711 XRX.XFRONT.XFE_O.XN.t11 VSS 0.38283f
C1712 XRX.XFRONT.XFE_O.XN.t12 VSS 0.38283f
C1713 XRX.XFRONT.XFE_O.XN.n29 VSS 1.2376f
C1714 XRX.XFRONT.XFE_O.XN.n30 VSS 0.55796f
C1715 XRX.XFRONT.XFE_O.XN.t6 VSS 1.67287f
C1716 XRX.XFRONT.XFE_O.XN.t7 VSS 0.38283f
C1717 XRX.XFRONT.XFE_O.XN.t8 VSS 0.38283f
C1718 XRX.XFRONT.XFE_O.XN.n31 VSS 1.2376f
C1719 XRX.XFRONT.XFE_O.XN.n32 VSS 0.68027f
C1720 XRX.XFRONT.XFE_O.XN.t9 VSS 0.38283f
C1721 XRX.XFRONT.XFE_O.XN.t10 VSS 0.38283f
C1722 XRX.XFRONT.XFE_O.XN.n33 VSS 1.2376f
C1723 XRX.XFRONT.XFE_O.XN.n34 VSS 0.33764f
C1724 XRX.XFRONT.XFE_O.XN.n35 VSS 0.69915f
C1725 XRX.XFRONT.XFE_O.XN.t4 VSS 0.4361f
C1726 XRX.XFRONT.XFE_O.XN.t5 VSS 0.4361f
C1727 XRX.XFRONT.XFE_O.XN.n36 VSS 1.23836f
C1728 XRX.XFRONT.XFE_O.XN.t34 VSS 1.71194f
C1729 XRX.XFRONT.XFE_O.XN.n37 VSS 0.969f
C1730 XRX.XFRONT.XFE_O.XN.n38 VSS 1.90694f
C1731 XRX.XFRONT.XFE_O.XN.n39 VSS 1.38561f
C1732 XRX.XFRONT.XFE_O.XN.t24 VSS 1.6301f
C1733 XRX.XFRONT.XFE_O.XN.t23 VSS 0.34118f
C1734 XRX.XFRONT.XFE_O.XN.t22 VSS 0.34118f
C1735 XRX.XFRONT.XFE_O.XN.n40 VSS 1.2376f
C1736 XRX.XFRONT.XFE_O.XN.n41 VSS 0.68027f
C1737 XRX.XFRONT.XFE_O.XN.t21 VSS 0.34118f
C1738 XRX.XFRONT.XFE_O.XN.t20 VSS 0.34118f
C1739 XRX.XFRONT.XFE_O.XN.n42 VSS 1.2376f
C1740 XRX.XFRONT.XFE_O.XN.n43 VSS 0.35512f
C1741 XRX.XFRONT.XFE_O.XN.t17 VSS 1.62732f
C1742 XRX.XFRONT.XFE_O.XN.t19 VSS 0.34118f
C1743 XRX.XFRONT.XFE_O.XN.t18 VSS 0.34118f
C1744 XRX.XFRONT.XFE_O.XN.n44 VSS 1.2376f
C1745 XRX.XFRONT.XFE_O.XN.n45 VSS 1.93393f
C1746 XRX.XFRONT.XFE_O.XN.n46 VSS 2.19485f
C1747 XRX.XFRONT.XFE_O.XN.t32 VSS 0.34396f
C1748 XRX.XFRONT.XFE_O.XN.t31 VSS 0.34118f
C1749 XRX.XFRONT.XFE_O.XN.n47 VSS 1.2413f
C1750 XRX.XFRONT.XFE_O.XN.t26 VSS 0.34118f
C1751 XRX.XFRONT.XFE_O.XN.t25 VSS 0.34118f
C1752 XRX.XFRONT.XFE_O.XN.n48 VSS 1.24729f
C1753 XRX.XFRONT.XFE_O.XN.t28 VSS 0.34118f
C1754 XRX.XFRONT.XFE_O.XN.t27 VSS 0.34118f
C1755 XRX.XFRONT.XFE_O.XN.n49 VSS 1.2376f
C1756 XRX.XFRONT.XFE_O.XN.n50 VSS 0.62716f
C1757 XRX.XFRONT.XFE_O.XN.t30 VSS 0.34118f
C1758 XRX.XFRONT.XFE_O.XN.t29 VSS 0.34118f
C1759 XRX.XFRONT.XFE_O.XN.n51 VSS 1.2376f
C1760 XRX.XFRONT.XFE_O.XN.n52 VSS 0.28523f
C1761 XRX.XFRONT.XFE_O.XN.n53 VSS 1.39559f
C1762 XRX.XFRONT.XFE_O.XN.n54 VSS 2.58108f
C1763 XRX.XFRONT.XFE_O.XN.n55 VSS 0.18804f
C1764 XRX.XFRONT.XFE_O.XN.n56 VSS 0.10621f
C1765 XRX.XFRONT.XFE_O.XN.n57 VSS 0.19535f
C1766 XRX.XFRONT.XFE_O.XN.n58 VSS 0.2094f
C1767 XRX.XFRONT.XFE_O.XN.n59 VSS 0.2094f
C1768 XRX.XFRONT.XFE_O.XN.n60 VSS 0.57977f
C1769 XRX.XFRONT.XFE_O.XN.n61 VSS 0.13428f
C1770 XRX.XFRONT.XFE_O.XN.n62 VSS 0.39522f
C1771 XRX.XFRONT.XFE_O.XN.n63 VSS 0.19535f
C1772 XRX.XFRONT.XFE_O.XN.n64 VSS 0.2094f
C1773 XRX.XFRONT.XFE_O.XN.n65 VSS 0.2094f
C1774 XRX.XFRONT.XFE_O.XN.n66 VSS 0.29347f
C1775 XRX.XFRONT.XFE_O.XN.n67 VSS 0.29196f
C1776 XRX.XFRONT.XFE_O.XN.n68 VSS 0.2639f
C1777 XRX.XFRONT.XFE_O.XN.n69 VSS 0.2094f
C1778 XRX.XFRONT.XFE_O.XN.n70 VSS 0.57977f
C1779 XRX.XFRONT.XFE_O.XN.n71 VSS 0.28137f
C1780 XRX.XFRONT.XFE_O.XN.n72 VSS 0.2094f
C1781 XRX.XFRONT.XFE_O.XN.n73 VSS 0.38313f
C1782 XRX.XFRONT.XFE_O.XN.n74 VSS 0.09546f
C1783 XRX.XFRONT.XFE_O.XN.n75 VSS 1.55365f
C1784 XRX.XFRONT.XFE_O.XN.n76 VSS 0.19535f
C1785 XRX.XFRONT.XFE_O.XN.n77 VSS 0.2094f
C1786 XRX.XFRONT.XFE_O.XN.n78 VSS 0.1979f
C1787 XRX.XFRONT.XFE_O.XN.n79 VSS 1.02723f
C1788 XRX.XFRONT.XFE_O.XN.n80 VSS 1.79458f
C1789 XRX.XFRONT.XFE_O.XN.n81 VSS 1.07867f
C1790 XRX.XFRONT.XFE_E.NREGEN.t16 VSS 1.49455f
C1791 XRX.XFRONT.XFE_E.NREGEN.t15 VSS 1.48473f
C1792 XRX.XFRONT.XFE_E.NREGEN.n0 VSS 1.51825f
C1793 XRX.XFRONT.XFE_E.NREGEN.t6 VSS 0.31872f
C1794 XRX.XFRONT.XFE_E.NREGEN.t1 VSS 0.31589f
C1795 XRX.XFRONT.XFE_E.NREGEN.n1 VSS 1.09768f
C1796 XRX.XFRONT.XFE_E.NREGEN.t30 VSS 0.31589f
C1797 XRX.XFRONT.XFE_E.NREGEN.t7 VSS 0.31589f
C1798 XRX.XFRONT.XFE_E.NREGEN.n2 VSS 1.08892f
C1799 XRX.XFRONT.XFE_E.NREGEN.n3 VSS 0.57192f
C1800 XRX.XFRONT.XFE_E.NREGEN.t9 VSS 0.31589f
C1801 XRX.XFRONT.XFE_E.NREGEN.t31 VSS 0.31589f
C1802 XRX.XFRONT.XFE_E.NREGEN.n4 VSS 1.08892f
C1803 XRX.XFRONT.XFE_E.NREGEN.t8 VSS 0.31589f
C1804 XRX.XFRONT.XFE_E.NREGEN.t10 VSS 0.31872f
C1805 XRX.XFRONT.XFE_E.NREGEN.n5 VSS 1.09768f
C1806 XRX.XFRONT.XFE_E.NREGEN.n6 VSS 0.62125f
C1807 XRX.XFRONT.XFE_E.NREGEN.n7 VSS 1.81763f
C1808 XRX.XFRONT.XFE_E.NREGEN.t14 VSS 1.49455f
C1809 XRX.XFRONT.XFE_E.NREGEN.t13 VSS 1.48473f
C1810 XRX.XFRONT.XFE_E.NREGEN.n8 VSS 1.51825f
C1811 XRX.XFRONT.XFE_E.NREGEN.t12 VSS 0.32406f
C1812 XRX.XFRONT.XFE_E.NREGEN.t33 VSS 0.32109f
C1813 XRX.XFRONT.XFE_E.NREGEN.n9 VSS 1.09768f
C1814 XRX.XFRONT.XFE_E.NREGEN.t5 VSS 0.32109f
C1815 XRX.XFRONT.XFE_E.NREGEN.t0 VSS 0.32109f
C1816 XRX.XFRONT.XFE_E.NREGEN.n10 VSS 1.08892f
C1817 XRX.XFRONT.XFE_E.NREGEN.n11 VSS 0.57192f
C1818 XRX.XFRONT.XFE_E.NREGEN.t32 VSS 0.32109f
C1819 XRX.XFRONT.XFE_E.NREGEN.t4 VSS 0.32109f
C1820 XRX.XFRONT.XFE_E.NREGEN.n12 VSS 1.08892f
C1821 XRX.XFRONT.XFE_E.NREGEN.t3 VSS 0.32109f
C1822 XRX.XFRONT.XFE_E.NREGEN.t2 VSS 0.32406f
C1823 XRX.XFRONT.XFE_E.NREGEN.n13 VSS 1.09768f
C1824 XRX.XFRONT.XFE_E.NREGEN.n14 VSS 0.62125f
C1825 XRX.XFRONT.XFE_E.NREGEN.n15 VSS 1.92761f
C1826 XRX.XFRONT.XFE_E.NREGEN.t27 VSS 0.41272f
C1827 XRX.XFRONT.XFE_E.NREGEN.t28 VSS 0.40894f
C1828 XRX.XFRONT.XFE_E.NREGEN.n16 VSS 1.09768f
C1829 XRX.XFRONT.XFE_E.NREGEN.t29 VSS 1.5365f
C1830 XRX.XFRONT.XFE_E.NREGEN.n17 VSS 0.79737f
C1831 XRX.XFRONT.XFE_E.NREGEN.n18 VSS 2.26f
C1832 XRX.XFRONT.XFE_E.NREGEN.t24 VSS 1.49196f
C1833 XRX.XFRONT.XFE_E.NREGEN.t23 VSS 0.35186f
C1834 XRX.XFRONT.XFE_E.NREGEN.t22 VSS 0.35186f
C1835 XRX.XFRONT.XFE_E.NREGEN.n19 VSS 1.08892f
C1836 XRX.XFRONT.XFE_E.NREGEN.n20 VSS 0.55175f
C1837 XRX.XFRONT.XFE_E.NREGEN.t17 VSS 1.49196f
C1838 XRX.XFRONT.XFE_E.NREGEN.t19 VSS 0.35186f
C1839 XRX.XFRONT.XFE_E.NREGEN.t18 VSS 0.35186f
C1840 XRX.XFRONT.XFE_E.NREGEN.n21 VSS 1.08892f
C1841 XRX.XFRONT.XFE_E.NREGEN.n22 VSS 0.6137f
C1842 XRX.XFRONT.XFE_E.NREGEN.t21 VSS 0.35186f
C1843 XRX.XFRONT.XFE_E.NREGEN.t20 VSS 0.35186f
C1844 XRX.XFRONT.XFE_E.NREGEN.n23 VSS 1.08892f
C1845 XRX.XFRONT.XFE_E.NREGEN.n24 VSS 0.26092f
C1846 XRX.XFRONT.XFE_E.NREGEN.n25 VSS 0.19669f
C1847 XRX.XFRONT.XFE_E.NREGEN.n26 VSS 2.0413f
C1848 XRX.XFRONT.XFE_E.NREGEN.t11 VSS 0.41907f
C1849 XRX.XFRONT.XFE_E.NREGEN.t25 VSS 0.41517f
C1850 XRX.XFRONT.XFE_E.NREGEN.n27 VSS 1.09768f
C1851 XRX.XFRONT.XFE_E.NREGEN.t26 VSS 1.54273f
C1852 XRX.XFRONT.XFE_E.NREGEN.n28 VSS 0.79737f
C1853 XRX.XFRONT.XFE_E.NREGEN.n29 VSS 1.22864f
C1854 XRX.XFRONT.XFE_O.NREGEN.t22 VSS 1.48473f
C1855 XRX.XFRONT.XFE_O.NREGEN.t21 VSS 1.49455f
C1856 XRX.XFRONT.XFE_O.NREGEN.n0 VSS 1.51825f
C1857 XRX.XFRONT.XFE_O.NREGEN.t7 VSS 0.32406f
C1858 XRX.XFRONT.XFE_O.NREGEN.t3 VSS 0.32109f
C1859 XRX.XFRONT.XFE_O.NREGEN.n1 VSS 1.09768f
C1860 XRX.XFRONT.XFE_O.NREGEN.t31 VSS 0.32109f
C1861 XRX.XFRONT.XFE_O.NREGEN.t5 VSS 0.32109f
C1862 XRX.XFRONT.XFE_O.NREGEN.n2 VSS 1.08892f
C1863 XRX.XFRONT.XFE_O.NREGEN.t1 VSS 0.32109f
C1864 XRX.XFRONT.XFE_O.NREGEN.t18 VSS 0.32406f
C1865 XRX.XFRONT.XFE_O.NREGEN.n3 VSS 1.09768f
C1866 XRX.XFRONT.XFE_O.NREGEN.t15 VSS 0.32109f
C1867 XRX.XFRONT.XFE_O.NREGEN.t17 VSS 0.32109f
C1868 XRX.XFRONT.XFE_O.NREGEN.n4 VSS 1.08892f
C1869 XRX.XFRONT.XFE_O.NREGEN.n5 VSS 0.57192f
C1870 XRX.XFRONT.XFE_O.NREGEN.n6 VSS 0.62125f
C1871 XRX.XFRONT.XFE_O.NREGEN.n7 VSS 1.92761f
C1872 XRX.XFRONT.XFE_O.NREGEN.t10 VSS 0.40894f
C1873 XRX.XFRONT.XFE_O.NREGEN.t33 VSS 0.41272f
C1874 XRX.XFRONT.XFE_O.NREGEN.n8 VSS 1.09768f
C1875 XRX.XFRONT.XFE_O.NREGEN.t9 VSS 1.5365f
C1876 XRX.XFRONT.XFE_O.NREGEN.n9 VSS 0.79737f
C1877 XRX.XFRONT.XFE_O.NREGEN.n10 VSS 2.26f
C1878 XRX.XFRONT.XFE_O.NREGEN.t30 VSS 1.49196f
C1879 XRX.XFRONT.XFE_O.NREGEN.t29 VSS 0.35186f
C1880 XRX.XFRONT.XFE_O.NREGEN.t28 VSS 0.35186f
C1881 XRX.XFRONT.XFE_O.NREGEN.n11 VSS 1.08892f
C1882 XRX.XFRONT.XFE_O.NREGEN.n12 VSS 0.6137f
C1883 XRX.XFRONT.XFE_O.NREGEN.t27 VSS 0.35186f
C1884 XRX.XFRONT.XFE_O.NREGEN.t26 VSS 0.35186f
C1885 XRX.XFRONT.XFE_O.NREGEN.n13 VSS 1.08892f
C1886 XRX.XFRONT.XFE_O.NREGEN.n14 VSS 0.26092f
C1887 XRX.XFRONT.XFE_O.NREGEN.t23 VSS 1.49196f
C1888 XRX.XFRONT.XFE_O.NREGEN.t25 VSS 0.35186f
C1889 XRX.XFRONT.XFE_O.NREGEN.t24 VSS 0.35186f
C1890 XRX.XFRONT.XFE_O.NREGEN.n15 VSS 1.08892f
C1891 XRX.XFRONT.XFE_O.NREGEN.n16 VSS 0.55175f
C1892 XRX.XFRONT.XFE_O.NREGEN.n17 VSS 0.19669f
C1893 XRX.XFRONT.XFE_O.NREGEN.n18 VSS 2.0413f
C1894 XRX.XFRONT.XFE_O.NREGEN.t12 VSS 0.41517f
C1895 XRX.XFRONT.XFE_O.NREGEN.t13 VSS 0.41907f
C1896 XRX.XFRONT.XFE_O.NREGEN.n19 VSS 1.09768f
C1897 XRX.XFRONT.XFE_O.NREGEN.t11 VSS 1.54273f
C1898 XRX.XFRONT.XFE_O.NREGEN.n20 VSS 0.79737f
C1899 XRX.XFRONT.XFE_O.NREGEN.n21 VSS 1.23801f
C1900 XRX.XFRONT.XFE_O.NREGEN.t20 VSS 1.48473f
C1901 XRX.XFRONT.XFE_O.NREGEN.t19 VSS 1.49455f
C1902 XRX.XFRONT.XFE_O.NREGEN.n22 VSS 1.51825f
C1903 XRX.XFRONT.XFE_O.NREGEN.t8 VSS 0.31872f
C1904 XRX.XFRONT.XFE_O.NREGEN.t0 VSS 0.31589f
C1905 XRX.XFRONT.XFE_O.NREGEN.n23 VSS 1.09768f
C1906 XRX.XFRONT.XFE_O.NREGEN.t32 VSS 0.31589f
C1907 XRX.XFRONT.XFE_O.NREGEN.t4 VSS 0.31589f
C1908 XRX.XFRONT.XFE_O.NREGEN.n24 VSS 1.08892f
C1909 XRX.XFRONT.XFE_O.NREGEN.t16 VSS 0.31589f
C1910 XRX.XFRONT.XFE_O.NREGEN.t14 VSS 0.31872f
C1911 XRX.XFRONT.XFE_O.NREGEN.n25 VSS 1.09768f
C1912 XRX.XFRONT.XFE_O.NREGEN.t6 VSS 0.31589f
C1913 XRX.XFRONT.XFE_O.NREGEN.t2 VSS 0.31589f
C1914 XRX.XFRONT.XFE_O.NREGEN.n26 VSS 1.08892f
C1915 XRX.XFRONT.XFE_O.NREGEN.n27 VSS 0.57192f
C1916 XRX.XFRONT.XFE_O.NREGEN.n28 VSS 0.62125f
C1917 XRX.XFRONT.XFE_O.NREGEN.n29 VSS 1.81724f
C1918 XRX.XFRONT.XFE_O.NREGEN.n30 VSS 0.46869f
C1919 XRX.XFRONT.XFE_E.BN.t1 VSS 0.79219f
C1920 XRX.XFRONT.XFE_E.BN.t0 VSS 0.79713f
C1921 XRX.XFRONT.XFE_E.BN.n0 VSS 0.36943f
C1922 XRX.XFRONT.XFE_E.BN.t9 VSS 0.79583f
C1923 XRX.XFRONT.XFE_E.BN.t8 VSS 0.22254f
C1924 XRX.XFRONT.XFE_E.BN.t7 VSS 0.22254f
C1925 XRX.XFRONT.XFE_E.BN.n1 VSS 0.54671f
C1926 XRX.XFRONT.XFE_E.BN.n2 VSS 0.27702f
C1927 XRX.XFRONT.XFE_E.BN.t2 VSS 0.79583f
C1928 XRX.XFRONT.XFE_E.BN.t4 VSS 0.22254f
C1929 XRX.XFRONT.XFE_E.BN.t3 VSS 0.22254f
C1930 XRX.XFRONT.XFE_E.BN.n3 VSS 0.54671f
C1931 XRX.XFRONT.XFE_E.BN.n4 VSS 0.30812f
C1932 XRX.XFRONT.XFE_E.BN.t6 VSS 0.22254f
C1933 XRX.XFRONT.XFE_E.BN.t5 VSS 0.22254f
C1934 XRX.XFRONT.XFE_E.BN.n5 VSS 0.54671f
C1935 XRX.XFRONT.XFE_E.BN.n6 VSS 0.131f
C1936 XRX.XFRONT.XFE_E.BN.n7 VSS 0.15187f
C1937 XRX.XFRONT.XFE_E.BN.n8 VSS 0.54152f
C1938 XRX.XFRONT.XFE_E.BN.n9 VSS 0.05092f
C1939 XRX.XFRONT.XFE_E.BN.n10 VSS 0.17589f
C1940 XRX.XFRONT.XFE_E.BN.n11 VSS 0.08694f
C1941 XRX.XFRONT.XFE_E.BN.n12 VSS 0.09319f
C1942 XRX.XFRONT.XFE_E.BN.n13 VSS 0.09319f
C1943 XRX.XFRONT.XFE_E.BN.n14 VSS 0.09319f
C1944 XRX.XFRONT.XFE_E.BN.n15 VSS 0.08694f
C1945 XRX.XFRONT.XFE_E.BN.n16 VSS 0.17589f
C1946 XRX.XFRONT.XFE_E.BN.n17 VSS 0.09319f
C1947 XRX.XFRONT.XFE_E.BN.n18 VSS 0.09319f
C1948 XRX.XFRONT.XFE_E.BN.n19 VSS 0.09319f
C1949 XRX.XFRONT.XFE_E.BN.n20 VSS 0.05092f
C1950 XRX.XFRONT.XFE_E.BN.n21 VSS 0.04865f
C1951 XRX.XFRONT.XFE_E.BN.n22 VSS 0.06043f
C1952 XRX.XFRONT.XFE_E.BN.n23 VSS 0.06043f
C1953 XRX.XFRONT.XFE_E.BN.n24 VSS 0.17589f
C1954 XRX.XFRONT.XFE_E.BN.n25 VSS 0.08694f
C1955 XRX.XFRONT.XFE_E.BN.n26 VSS 0.09319f
C1956 XRX.XFRONT.XFE_E.BN.n27 VSS 0.09319f
C1957 XRX.XFRONT.XFE_E.BN.n28 VSS 0.09319f
C1958 XRX.XFRONT.XFE_E.BN.n29 VSS 0.09319f
C1959 XRX.XFRONT.XFE_E.BN.n30 VSS 0.08807f
C1960 XRX.XFRONT.XFE_E.BN.n31 VSS 0.27422f
C1961 XRX.XFRONT.XFE_E.BN.n32 VSS 0.6628f
C1962 XRX.XFRONT.XFE_E.SXN.t0 VSS 1.07869f
C1963 XRX.XFRONT.XFE_E.SXN.t1 VSS 0.33986f
C1964 XRX.XFRONT.XFE_E.SXN.t6 VSS 0.33986f
C1965 XRX.XFRONT.XFE_E.SXN.n0 VSS 0.70719f
C1966 XRX.XFRONT.XFE_E.SXN.n1 VSS 0.38872f
C1967 XRX.XFRONT.XFE_E.SXN.t7 VSS 0.33986f
C1968 XRX.XFRONT.XFE_E.SXN.t4 VSS 0.33986f
C1969 XRX.XFRONT.XFE_E.SXN.n2 VSS 0.70719f
C1970 XRX.XFRONT.XFE_E.SXN.n3 VSS 0.20292f
C1971 XRX.XFRONT.XFE_E.SXN.t5 VSS 0.33986f
C1972 XRX.XFRONT.XFE_E.SXN.t8 VSS 0.33986f
C1973 XRX.XFRONT.XFE_E.SXN.n4 VSS 0.70719f
C1974 XRX.XFRONT.XFE_E.SXN.n5 VSS 0.20292f
C1975 XRX.XFRONT.XFE_E.SXN.t9 VSS 1.06845f
C1976 XRX.XFRONT.XFE_E.SXN.n6 VSS 0.90335f
C1977 XRX.XFRONT.XFE_E.SXN.n7 VSS 0.42389f
C1978 XRX.XFRONT.XFE_E.SXN.n8 VSS 0.06537f
C1979 XRX.XFRONT.XFE_E.SXN.n9 VSS 0.22584f
C1980 XRX.XFRONT.XFE_E.SXN.n10 VSS 0.11163f
C1981 XRX.XFRONT.XFE_E.SXN.n11 VSS 0.11965f
C1982 XRX.XFRONT.XFE_E.SXN.n12 VSS 0.11965f
C1983 XRX.XFRONT.XFE_E.SXN.n13 VSS 0.11965f
C1984 XRX.XFRONT.XFE_E.SXN.n14 VSS 0.11163f
C1985 XRX.XFRONT.XFE_E.SXN.n15 VSS 0.22584f
C1986 XRX.XFRONT.XFE_E.SXN.n16 VSS 0.11965f
C1987 XRX.XFRONT.XFE_E.SXN.n17 VSS 0.11965f
C1988 XRX.XFRONT.XFE_E.SXN.n18 VSS 0.11965f
C1989 XRX.XFRONT.XFE_E.SXN.n19 VSS 0.06537f
C1990 XRX.XFRONT.XFE_E.SXN.n20 VSS 0.08065f
C1991 XRX.XFRONT.XFE_E.SXN.n21 VSS 1.52553f
C1992 XRX.XFRONT.XFE_E.SXN.t10 VSS 1.077f
C1993 XRX.XFRONT.XFE_E.SXN.t11 VSS 0.33986f
C1994 XRX.XFRONT.XFE_E.SXN.t2 VSS 0.33986f
C1995 XRX.XFRONT.XFE_E.SXN.n22 VSS 0.70198f
C1996 XRX.XFRONT.XFE_E.SXN.n23 VSS 0.39562f
C1997 XRX.XFRONT.XFE_E.SXN.t3 VSS 1.06675f
C1998 XRX.XFRONT.XFE_E.SXN.n24 VSS 0.93086f
C1999 XRX.XFRONT.XFE_E.SXN.n25 VSS 1.75357f
C2000 XRX.XFRONT.XFE_E.SXP.n0 VSS 0.44369f
C2001 XRX.XFRONT.XFE_E.SXP.n1 VSS 0.06633f
C2002 XRX.XFRONT.XFE_E.SXP.n2 VSS 0.22913f
C2003 XRX.XFRONT.XFE_E.SXP.n3 VSS 0.11325f
C2004 XRX.XFRONT.XFE_E.SXP.n4 VSS 0.1214f
C2005 XRX.XFRONT.XFE_E.SXP.n5 VSS 0.1214f
C2006 XRX.XFRONT.XFE_E.SXP.n6 VSS 0.1214f
C2007 XRX.XFRONT.XFE_E.SXP.n7 VSS 0.11325f
C2008 XRX.XFRONT.XFE_E.SXP.n8 VSS 0.22913f
C2009 XRX.XFRONT.XFE_E.SXP.n9 VSS 0.1214f
C2010 XRX.XFRONT.XFE_E.SXP.n10 VSS 0.1214f
C2011 XRX.XFRONT.XFE_E.SXP.n11 VSS 0.1214f
C2012 XRX.XFRONT.XFE_E.SXP.n12 VSS 0.06633f
C2013 XRX.XFRONT.XFE_E.SXP.n13 VSS 0.07275f
C2014 XRX.XFRONT.XFE_E.SXP.n14 VSS 0.88712f
C2015 XRX.XFRONT.XFE_E.SXP.t5 VSS 1.08502f
C2016 XRX.XFRONT.XFE_E.SXP.t3 VSS 0.33562f
C2017 XRX.XFRONT.XFE_E.SXP.t4 VSS 0.33562f
C2018 XRX.XFRONT.XFE_E.SXP.n15 VSS 0.71748f
C2019 XRX.XFRONT.XFE_E.SXP.n16 VSS 0.39438f
C2020 XRX.XFRONT.XFE_E.SXP.t1 VSS 0.33562f
C2021 XRX.XFRONT.XFE_E.SXP.t2 VSS 0.33562f
C2022 XRX.XFRONT.XFE_E.SXP.n17 VSS 0.71748f
C2023 XRX.XFRONT.XFE_E.SXP.n18 VSS 0.20587f
C2024 XRX.XFRONT.XFE_E.SXP.t11 VSS 0.33562f
C2025 XRX.XFRONT.XFE_E.SXP.t0 VSS 0.33562f
C2026 XRX.XFRONT.XFE_E.SXP.n19 VSS 0.71748f
C2027 XRX.XFRONT.XFE_E.SXP.n20 VSS 0.20587f
C2028 XRX.XFRONT.XFE_E.SXP.t10 VSS 1.07481f
C2029 XRX.XFRONT.XFE_E.SXP.n21 VSS 0.5855f
C2030 XRX.XFRONT.XFE_E.SXP.t9 VSS 1.08331f
C2031 XRX.XFRONT.XFE_E.SXP.t7 VSS 0.33562f
C2032 XRX.XFRONT.XFE_E.SXP.t8 VSS 0.33562f
C2033 XRX.XFRONT.XFE_E.SXP.n22 VSS 0.71219f
C2034 XRX.XFRONT.XFE_E.SXP.n23 VSS 0.40138f
C2035 XRX.XFRONT.XFE_E.SXP.t6 VSS 1.07309f
C2036 XRX.XFRONT.XFE_E.SXP.n24 VSS 0.57887f
C2037 XRX.XFRONT.XFE_E.SXP.n25 VSS 1.39041f
C2038 XRX.XFRONT.XFE_E.BP.n0 VSS 0.04911f
C2039 XRX.XFRONT.XFE_E.BP.n1 VSS 0.16966f
C2040 XRX.XFRONT.XFE_E.BP.n2 VSS 0.08386f
C2041 XRX.XFRONT.XFE_E.BP.n3 VSS 0.08989f
C2042 XRX.XFRONT.XFE_E.BP.n4 VSS 0.08989f
C2043 XRX.XFRONT.XFE_E.BP.n5 VSS 0.08989f
C2044 XRX.XFRONT.XFE_E.BP.n6 VSS 0.08386f
C2045 XRX.XFRONT.XFE_E.BP.n7 VSS 0.16966f
C2046 XRX.XFRONT.XFE_E.BP.n8 VSS 0.08989f
C2047 XRX.XFRONT.XFE_E.BP.n9 VSS 0.08989f
C2048 XRX.XFRONT.XFE_E.BP.n10 VSS 0.08989f
C2049 XRX.XFRONT.XFE_E.BP.n11 VSS 0.04911f
C2050 XRX.XFRONT.XFE_E.BP.n12 VSS 0.05215f
C2051 XRX.XFRONT.XFE_E.BP.n13 VSS 0.05829f
C2052 XRX.XFRONT.XFE_E.BP.n14 VSS 0.08989f
C2053 XRX.XFRONT.XFE_E.BP.n15 VSS 0.08989f
C2054 XRX.XFRONT.XFE_E.BP.n16 VSS 0.08386f
C2055 XRX.XFRONT.XFE_E.BP.n17 VSS 0.16966f
C2056 XRX.XFRONT.XFE_E.BP.n18 VSS 0.05829f
C2057 XRX.XFRONT.XFE_E.BP.n19 VSS 0.08989f
C2058 XRX.XFRONT.XFE_E.BP.n20 VSS 0.08989f
C2059 XRX.XFRONT.XFE_E.BP.n21 VSS 0.08495f
C2060 XRX.XFRONT.XFE_E.BP.n22 VSS 0.25147f
C2061 XRX.XFRONT.XFE_E.BP.n23 VSS 0.57807f
C2062 XRX.XFRONT.XFE_E.BP.t1 VSS 0.77005f
C2063 XRX.XFRONT.XFE_E.BP.t2 VSS 0.77482f
C2064 XRX.XFRONT.XFE_E.BP.n24 VSS 0.37042f
C2065 XRX.XFRONT.XFE_E.BP.t7 VSS 0.77356f
C2066 XRX.XFRONT.XFE_E.BP.t8 VSS 0.22046f
C2067 XRX.XFRONT.XFE_E.BP.t9 VSS 0.22046f
C2068 XRX.XFRONT.XFE_E.BP.n25 VSS 0.52735f
C2069 XRX.XFRONT.XFE_E.BP.n26 VSS 0.26721f
C2070 XRX.XFRONT.XFE_E.BP.t0 VSS 0.77356f
C2071 XRX.XFRONT.XFE_E.BP.t5 VSS 0.22046f
C2072 XRX.XFRONT.XFE_E.BP.t6 VSS 0.22046f
C2073 XRX.XFRONT.XFE_E.BP.n27 VSS 0.52735f
C2074 XRX.XFRONT.XFE_E.BP.n28 VSS 0.29721f
C2075 XRX.XFRONT.XFE_E.BP.t3 VSS 0.22046f
C2076 XRX.XFRONT.XFE_E.BP.t4 VSS 0.22046f
C2077 XRX.XFRONT.XFE_E.BP.n29 VSS 0.52735f
C2078 XRX.XFRONT.XFE_E.BP.n30 VSS 0.12636f
C2079 XRX.XFRONT.XFE_E.BP.n31 VSS 0.13242f
C2080 XRX.XFRONT.XFE_E.BP.n32 VSS 0.57347f
C2081 XRX.XFRONT.XFE_O.BP.t1 VSS 0.77482f
C2082 XRX.XFRONT.XFE_O.BP.t0 VSS 0.77005f
C2083 XRX.XFRONT.XFE_O.BP.n0 VSS 0.37042f
C2084 XRX.XFRONT.XFE_O.BP.t9 VSS 0.77356f
C2085 XRX.XFRONT.XFE_O.BP.t8 VSS 0.22046f
C2086 XRX.XFRONT.XFE_O.BP.t7 VSS 0.22046f
C2087 XRX.XFRONT.XFE_O.BP.n1 VSS 0.52735f
C2088 XRX.XFRONT.XFE_O.BP.n2 VSS 0.29721f
C2089 XRX.XFRONT.XFE_O.BP.t6 VSS 0.22046f
C2090 XRX.XFRONT.XFE_O.BP.t5 VSS 0.22046f
C2091 XRX.XFRONT.XFE_O.BP.n3 VSS 0.52735f
C2092 XRX.XFRONT.XFE_O.BP.n4 VSS 0.12636f
C2093 XRX.XFRONT.XFE_O.BP.t2 VSS 0.77356f
C2094 XRX.XFRONT.XFE_O.BP.t4 VSS 0.22046f
C2095 XRX.XFRONT.XFE_O.BP.t3 VSS 0.22046f
C2096 XRX.XFRONT.XFE_O.BP.n5 VSS 0.52735f
C2097 XRX.XFRONT.XFE_O.BP.n6 VSS 0.26721f
C2098 XRX.XFRONT.XFE_O.BP.n7 VSS 0.13242f
C2099 XRX.XFRONT.XFE_O.BP.n8 VSS 0.57561f
C2100 XRX.XFRONT.XFE_O.BP.n9 VSS 0.04911f
C2101 XRX.XFRONT.XFE_O.BP.n10 VSS 0.16966f
C2102 XRX.XFRONT.XFE_O.BP.n11 VSS 0.08386f
C2103 XRX.XFRONT.XFE_O.BP.n12 VSS 0.08989f
C2104 XRX.XFRONT.XFE_O.BP.n13 VSS 0.08989f
C2105 XRX.XFRONT.XFE_O.BP.n14 VSS 0.08989f
C2106 XRX.XFRONT.XFE_O.BP.n15 VSS 0.08386f
C2107 XRX.XFRONT.XFE_O.BP.n16 VSS 0.16966f
C2108 XRX.XFRONT.XFE_O.BP.n17 VSS 0.08989f
C2109 XRX.XFRONT.XFE_O.BP.n18 VSS 0.08989f
C2110 XRX.XFRONT.XFE_O.BP.n19 VSS 0.08989f
C2111 XRX.XFRONT.XFE_O.BP.n20 VSS 0.04911f
C2112 XRX.XFRONT.XFE_O.BP.n21 VSS 0.05215f
C2113 XRX.XFRONT.XFE_O.BP.n22 VSS 0.05829f
C2114 XRX.XFRONT.XFE_O.BP.n23 VSS 0.05829f
C2115 XRX.XFRONT.XFE_O.BP.n24 VSS 0.16966f
C2116 XRX.XFRONT.XFE_O.BP.n25 VSS 0.08386f
C2117 XRX.XFRONT.XFE_O.BP.n26 VSS 0.08989f
C2118 XRX.XFRONT.XFE_O.BP.n27 VSS 0.08989f
C2119 XRX.XFRONT.XFE_O.BP.n28 VSS 0.08989f
C2120 XRX.XFRONT.XFE_O.BP.n29 VSS 0.08989f
C2121 XRX.XFRONT.XFE_O.BP.n30 VSS 0.08495f
C2122 XRX.XFRONT.XFE_O.BP.n31 VSS 0.25147f
C2123 XRX.XFRONT.XFE_O.BP.n32 VSS 0.57788f
C2124 XRX.XFRONT.XFE_O.BP.n33 VSS 0.34059f
C2125 XRX.XFRONT.XFE_O.SXP.t4 VSS 1.08502f
C2126 XRX.XFRONT.XFE_O.SXP.t0 VSS 0.33562f
C2127 XRX.XFRONT.XFE_O.SXP.t1 VSS 0.33562f
C2128 XRX.XFRONT.XFE_O.SXP.n0 VSS 0.71748f
C2129 XRX.XFRONT.XFE_O.SXP.n1 VSS 0.39438f
C2130 XRX.XFRONT.XFE_O.SXP.t8 VSS 0.33562f
C2131 XRX.XFRONT.XFE_O.SXP.t9 VSS 0.33562f
C2132 XRX.XFRONT.XFE_O.SXP.n2 VSS 0.71748f
C2133 XRX.XFRONT.XFE_O.SXP.n3 VSS 0.20587f
C2134 XRX.XFRONT.XFE_O.SXP.t5 VSS 0.33562f
C2135 XRX.XFRONT.XFE_O.SXP.t6 VSS 0.33562f
C2136 XRX.XFRONT.XFE_O.SXP.n4 VSS 0.71748f
C2137 XRX.XFRONT.XFE_O.SXP.n5 VSS 0.20587f
C2138 XRX.XFRONT.XFE_O.SXP.t7 VSS 1.07481f
C2139 XRX.XFRONT.XFE_O.SXP.n6 VSS 0.5855f
C2140 XRX.XFRONT.XFE_O.SXP.t10 VSS 1.08331f
C2141 XRX.XFRONT.XFE_O.SXP.t11 VSS 0.33562f
C2142 XRX.XFRONT.XFE_O.SXP.t2 VSS 0.33562f
C2143 XRX.XFRONT.XFE_O.SXP.n7 VSS 0.71219f
C2144 XRX.XFRONT.XFE_O.SXP.n8 VSS 0.40138f
C2145 XRX.XFRONT.XFE_O.SXP.t3 VSS 1.07309f
C2146 XRX.XFRONT.XFE_O.SXP.n9 VSS 0.57887f
C2147 XRX.XFRONT.XFE_O.SXP.n10 VSS 1.39499f
C2148 XRX.XFRONT.XFE_O.SXP.n11 VSS 0.44369f
C2149 XRX.XFRONT.XFE_O.SXP.n12 VSS 0.06633f
C2150 XRX.XFRONT.XFE_O.SXP.n13 VSS 0.22913f
C2151 XRX.XFRONT.XFE_O.SXP.n14 VSS 0.11325f
C2152 XRX.XFRONT.XFE_O.SXP.n15 VSS 0.1214f
C2153 XRX.XFRONT.XFE_O.SXP.n16 VSS 0.1214f
C2154 XRX.XFRONT.XFE_O.SXP.n17 VSS 0.1214f
C2155 XRX.XFRONT.XFE_O.SXP.n18 VSS 0.11325f
C2156 XRX.XFRONT.XFE_O.SXP.n19 VSS 0.22913f
C2157 XRX.XFRONT.XFE_O.SXP.n20 VSS 0.1214f
C2158 XRX.XFRONT.XFE_O.SXP.n21 VSS 0.1214f
C2159 XRX.XFRONT.XFE_O.SXP.n22 VSS 0.1214f
C2160 XRX.XFRONT.XFE_O.SXP.n23 VSS 0.06633f
C2161 XRX.XFRONT.XFE_O.SXP.n24 VSS 0.07275f
C2162 XRX.XFRONT.XFE_O.SXP.n25 VSS 0.88687f
C2163 XRX.XFRONT.XFE_O.SXP.n26 VSS 1.78078f
C2164 XRX.XFRONT.XFE_O.SXN.n0 VSS 0.42389f
C2165 XRX.XFRONT.XFE_O.SXN.n1 VSS 0.06537f
C2166 XRX.XFRONT.XFE_O.SXN.n2 VSS 0.22584f
C2167 XRX.XFRONT.XFE_O.SXN.n3 VSS 0.11163f
C2168 XRX.XFRONT.XFE_O.SXN.n4 VSS 0.11965f
C2169 XRX.XFRONT.XFE_O.SXN.n5 VSS 0.11965f
C2170 XRX.XFRONT.XFE_O.SXN.n6 VSS 0.11965f
C2171 XRX.XFRONT.XFE_O.SXN.n7 VSS 0.11163f
C2172 XRX.XFRONT.XFE_O.SXN.n8 VSS 0.22584f
C2173 XRX.XFRONT.XFE_O.SXN.n9 VSS 0.11965f
C2174 XRX.XFRONT.XFE_O.SXN.n10 VSS 0.11965f
C2175 XRX.XFRONT.XFE_O.SXN.n11 VSS 0.11965f
C2176 XRX.XFRONT.XFE_O.SXN.n12 VSS 0.06537f
C2177 XRX.XFRONT.XFE_O.SXN.n13 VSS 0.08065f
C2178 XRX.XFRONT.XFE_O.SXN.n14 VSS 1.52553f
C2179 XRX.XFRONT.XFE_O.SXN.t0 VSS 1.077f
C2180 XRX.XFRONT.XFE_O.SXN.t4 VSS 0.33986f
C2181 XRX.XFRONT.XFE_O.SXN.t5 VSS 0.33986f
C2182 XRX.XFRONT.XFE_O.SXN.n15 VSS 0.70198f
C2183 XRX.XFRONT.XFE_O.SXN.n16 VSS 0.39562f
C2184 XRX.XFRONT.XFE_O.SXN.t3 VSS 1.06675f
C2185 XRX.XFRONT.XFE_O.SXN.n17 VSS 0.93086f
C2186 XRX.XFRONT.XFE_O.SXN.n18 VSS 1.75961f
C2187 XRX.XFRONT.XFE_O.SXN.t8 VSS 1.07869f
C2188 XRX.XFRONT.XFE_O.SXN.t6 VSS 0.33986f
C2189 XRX.XFRONT.XFE_O.SXN.t7 VSS 0.33986f
C2190 XRX.XFRONT.XFE_O.SXN.n19 VSS 0.70719f
C2191 XRX.XFRONT.XFE_O.SXN.n20 VSS 0.38872f
C2192 XRX.XFRONT.XFE_O.SXN.t10 VSS 0.33986f
C2193 XRX.XFRONT.XFE_O.SXN.t11 VSS 0.33986f
C2194 XRX.XFRONT.XFE_O.SXN.n21 VSS 0.70719f
C2195 XRX.XFRONT.XFE_O.SXN.n22 VSS 0.20292f
C2196 XRX.XFRONT.XFE_O.SXN.t2 VSS 0.33986f
C2197 XRX.XFRONT.XFE_O.SXN.t9 VSS 0.33986f
C2198 XRX.XFRONT.XFE_O.SXN.n23 VSS 0.70719f
C2199 XRX.XFRONT.XFE_O.SXN.n24 VSS 0.20292f
C2200 XRX.XFRONT.XFE_O.SXN.t1 VSS 1.06845f
C2201 XRX.XFRONT.XFE_O.SXN.n25 VSS 0.90216f
C2202 XRX.XFRONT.XFE_O.SXN.n26 VSS 0.5459f
C2203 XRX.XFRONT.XFE_O.BN.n0 VSS 0.05092f
C2204 XRX.XFRONT.XFE_O.BN.n1 VSS 0.17589f
C2205 XRX.XFRONT.XFE_O.BN.n2 VSS 0.08694f
C2206 XRX.XFRONT.XFE_O.BN.n3 VSS 0.09319f
C2207 XRX.XFRONT.XFE_O.BN.n4 VSS 0.09319f
C2208 XRX.XFRONT.XFE_O.BN.n5 VSS 0.09319f
C2209 XRX.XFRONT.XFE_O.BN.n6 VSS 0.08694f
C2210 XRX.XFRONT.XFE_O.BN.n7 VSS 0.17589f
C2211 XRX.XFRONT.XFE_O.BN.n8 VSS 0.09319f
C2212 XRX.XFRONT.XFE_O.BN.n9 VSS 0.09319f
C2213 XRX.XFRONT.XFE_O.BN.n10 VSS 0.09319f
C2214 XRX.XFRONT.XFE_O.BN.n11 VSS 0.05092f
C2215 XRX.XFRONT.XFE_O.BN.n12 VSS 0.04865f
C2216 XRX.XFRONT.XFE_O.BN.n13 VSS 0.06043f
C2217 XRX.XFRONT.XFE_O.BN.n14 VSS 0.09319f
C2218 XRX.XFRONT.XFE_O.BN.n15 VSS 0.09319f
C2219 XRX.XFRONT.XFE_O.BN.n16 VSS 0.08694f
C2220 XRX.XFRONT.XFE_O.BN.n17 VSS 0.17589f
C2221 XRX.XFRONT.XFE_O.BN.n18 VSS 0.06043f
C2222 XRX.XFRONT.XFE_O.BN.n19 VSS 0.09319f
C2223 XRX.XFRONT.XFE_O.BN.n20 VSS 0.09319f
C2224 XRX.XFRONT.XFE_O.BN.n21 VSS 0.08807f
C2225 XRX.XFRONT.XFE_O.BN.n22 VSS 0.27422f
C2226 XRX.XFRONT.XFE_O.BN.n23 VSS 0.66526f
C2227 XRX.XFRONT.XFE_O.BN.t8 VSS 0.79713f
C2228 XRX.XFRONT.XFE_O.BN.t9 VSS 0.79219f
C2229 XRX.XFRONT.XFE_O.BN.n24 VSS 0.36943f
C2230 XRX.XFRONT.XFE_O.BN.t0 VSS 0.79583f
C2231 XRX.XFRONT.XFE_O.BN.t1 VSS 0.22254f
C2232 XRX.XFRONT.XFE_O.BN.t2 VSS 0.22254f
C2233 XRX.XFRONT.XFE_O.BN.n25 VSS 0.54671f
C2234 XRX.XFRONT.XFE_O.BN.n26 VSS 0.30812f
C2235 XRX.XFRONT.XFE_O.BN.t3 VSS 0.22254f
C2236 XRX.XFRONT.XFE_O.BN.t4 VSS 0.22254f
C2237 XRX.XFRONT.XFE_O.BN.n27 VSS 0.54671f
C2238 XRX.XFRONT.XFE_O.BN.n28 VSS 0.131f
C2239 XRX.XFRONT.XFE_O.BN.t7 VSS 0.79583f
C2240 XRX.XFRONT.XFE_O.BN.t5 VSS 0.22254f
C2241 XRX.XFRONT.XFE_O.BN.t6 VSS 0.22254f
C2242 XRX.XFRONT.XFE_O.BN.n29 VSS 0.54671f
C2243 XRX.XFRONT.XFE_O.BN.n30 VSS 0.27702f
C2244 XRX.XFRONT.XFE_O.BN.n31 VSS 0.15187f
C2245 XRX.XFRONT.XFE_O.BN.n32 VSS 0.54133f
C2246 XRX.XFRONT.XFE_O.BN.n33 VSS 0.40957f
C2247 XRX.XFRONT.XFE_E.NTAIL.t5 VSS 0.17332f
C2248 XRX.XFRONT.XFE_E.NTAIL.t4 VSS 0.17332f
C2249 XRX.XFRONT.XFE_E.NTAIL.n0 VSS 0.91027f
C2250 XRX.XFRONT.XFE_E.NTAIL.t2 VSS 0.19081f
C2251 XRX.XFRONT.XFE_E.NTAIL.t3 VSS 0.19081f
C2252 XRX.XFRONT.XFE_E.NTAIL.n1 VSS 0.97526f
C2253 XRX.XFRONT.XFE_E.NTAIL.t1 VSS 0.92647f
C2254 XRX.XFRONT.XFE_E.NTAIL.t0 VSS 0.93208f
C2255 XRX.XFRONT.XFE_E.NTAIL.n2 VSS 0.44321f
C2256 XRX.XFRONT.XFE_E.NTAIL.n3 VSS 1.31879f
C2257 XRX.XFRONT.XFE_E.NTAIL.t11 VSS 0.84943f
C2258 XRX.XFRONT.XFE_E.NTAIL.t6 VSS 0.85119f
C2259 XRX.XFRONT.XFE_E.NTAIL.t8 VSS 0.20358f
C2260 XRX.XFRONT.XFE_E.NTAIL.t7 VSS 0.20358f
C2261 XRX.XFRONT.XFE_E.NTAIL.n4 VSS 0.61999f
C2262 XRX.XFRONT.XFE_E.NTAIL.n5 VSS 0.34942f
C2263 XRX.XFRONT.XFE_E.NTAIL.t10 VSS 0.20358f
C2264 XRX.XFRONT.XFE_E.NTAIL.t9 VSS 0.20358f
C2265 XRX.XFRONT.XFE_E.NTAIL.n6 VSS 0.61999f
C2266 XRX.XFRONT.XFE_E.NTAIL.n7 VSS 0.14856f
C2267 XRX.XFRONT.XFE_E.NTAIL.n8 VSS 0.31063f
C2268 XRX.XFRONT.XFE_E.NTAIL.n9 VSS 0.61878f
C2269 XRX.XFRONT.XFE_O.NTAIL.t10 VSS 0.19075f
C2270 XRX.XFRONT.XFE_O.NTAIL.t11 VSS 0.19075f
C2271 XRX.XFRONT.XFE_O.NTAIL.n0 VSS 0.97526f
C2272 XRX.XFRONT.XFE_O.NTAIL.t1 VSS 0.93208f
C2273 XRX.XFRONT.XFE_O.NTAIL.t0 VSS 0.92647f
C2274 XRX.XFRONT.XFE_O.NTAIL.n1 VSS 0.44321f
C2275 XRX.XFRONT.XFE_O.NTAIL.n2 VSS 1.31879f
C2276 XRX.XFRONT.XFE_O.NTAIL.t7 VSS 0.85119f
C2277 XRX.XFRONT.XFE_O.NTAIL.t6 VSS 0.20358f
C2278 XRX.XFRONT.XFE_O.NTAIL.t5 VSS 0.20358f
C2279 XRX.XFRONT.XFE_O.NTAIL.n3 VSS 0.61999f
C2280 XRX.XFRONT.XFE_O.NTAIL.n4 VSS 0.34942f
C2281 XRX.XFRONT.XFE_O.NTAIL.t4 VSS 0.20358f
C2282 XRX.XFRONT.XFE_O.NTAIL.t3 VSS 0.20358f
C2283 XRX.XFRONT.XFE_O.NTAIL.n5 VSS 0.61999f
C2284 XRX.XFRONT.XFE_O.NTAIL.n6 VSS 0.14856f
C2285 XRX.XFRONT.XFE_O.NTAIL.t2 VSS 0.84943f
C2286 XRX.XFRONT.XFE_O.NTAIL.n7 VSS 0.31063f
C2287 XRX.XFRONT.XFE_O.NTAIL.n8 VSS 0.62412f
C2288 XRX.XFRONT.XFE_O.NTAIL.t9 VSS 0.17348f
C2289 XRX.XFRONT.XFE_O.NTAIL.t8 VSS 0.17348f
C2290 XRX.XFRONT.XFE_O.NTAIL.n9 VSS 0.90948f
C2291 XRX.XFRONT.XFE_O.NTAIL.n10 VSS 0.53201f
C2292 a_948_44200.t2 VSS 0.62246f
C2293 a_948_44200.t5 VSS 0.1331f
C2294 a_948_44200.t4 VSS 0.1331f
C2295 a_948_44200.n0 VSS 0.51748f
C2296 a_948_44200.t1 VSS 0.13204f
C2297 a_948_44200.t0 VSS 0.13204f
C2298 a_948_44200.n1 VSS 0.47973f
C2299 a_948_44200.n2 VSS 3.66241f
C2300 a_948_44200.n3 VSS 0.50661f
C2301 a_948_44200.t3 VSS 0.62246f
C2302 a_2548_44200.t2 VSS 0.83067f
C2303 a_2548_44200.t5 VSS 0.16249f
C2304 a_2548_44200.t4 VSS 0.16249f
C2305 a_2548_44200.n0 VSS 0.62947f
C2306 a_2548_44200.t1 VSS 0.17593f
C2307 a_2548_44200.t0 VSS 0.17593f
C2308 a_2548_44200.n1 VSS 0.59103f
C2309 a_2548_44200.n2 VSS 2.81846f
C2310 a_2548_44200.n3 VSS 0.69295f
C2311 a_2548_44200.t3 VSS 0.83067f
C2312 a_10548_44200.t2 VSS 0.60188f
C2313 a_10548_44200.t5 VSS 0.13032f
C2314 a_10548_44200.t4 VSS 0.13032f
C2315 a_10548_44200.n0 VSS 0.50161f
C2316 a_10548_44200.t1 VSS 0.12927f
C2317 a_10548_44200.t0 VSS 0.12927f
C2318 a_10548_44200.n1 VSS 0.46501f
C2319 a_10548_44200.n2 VSS 3.55006f
C2320 a_10548_44200.n3 VSS 0.49107f
C2321 a_10548_44200.t3 VSS 0.60188f
C2322 a_12148_44200.t0 VSS 0.82401f
C2323 a_12148_44200.t5 VSS 0.17456f
C2324 a_12148_44200.t4 VSS 0.17456f
C2325 a_12148_44200.n0 VSS 0.62265f
C2326 a_12148_44200.t3 VSS 0.16129f
C2327 a_12148_44200.t2 VSS 0.16129f
C2328 a_12148_44200.n1 VSS 0.58462f
C2329 a_12148_44200.n2 VSS 2.78788f
C2330 a_12148_44200.n3 VSS 0.68544f
C2331 a_12148_44200.t1 VSS 0.82401f
C2332 a_2148_41600.t5 VSS 0.1448f
C2333 a_2148_41600.t7 VSS 0.59332f
C2334 a_2148_41600.n0 VSS 0.11907f
C2335 a_2148_41600.t2 VSS 0.10946f
C2336 a_2148_41600.t3 VSS 0.10946f
C2337 a_2148_41600.n1 VSS 0.38577f
C2338 a_2148_41600.t0 VSS 0.1116f
C2339 a_2148_41600.t1 VSS 0.1116f
C2340 a_2148_41600.n2 VSS 0.38577f
C2341 a_2148_41600.n3 VSS 1.18313f
C2342 a_2148_41600.n4 VSS 0.35665f
C2343 a_2148_41600.t4 VSS 0.59158f
C2344 a_2148_41600.n5 VSS 0.12082f
C2345 a_2148_41600.n6 VSS 0.13505f
C2346 a_2148_41600.n7 VSS 0.41454f
C2347 a_2148_41600.t6 VSS 0.1448f
C2348 a_11748_41600.t5 VSS 0.14207f
C2349 a_11748_41600.t7 VSS 0.57975f
C2350 a_11748_41600.n0 VSS 0.11619f
C2351 a_11748_41600.t0 VSS 0.10941f
C2352 a_11748_41600.t1 VSS 0.10941f
C2353 a_11748_41600.n1 VSS 0.37643f
C2354 a_11748_41600.t3 VSS 0.10728f
C2355 a_11748_41600.t2 VSS 0.10728f
C2356 a_11748_41600.n2 VSS 0.37643f
C2357 a_11748_41600.n3 VSS 1.15448f
C2358 a_11748_41600.n4 VSS 0.34802f
C2359 a_11748_41600.t4 VSS 0.57804f
C2360 a_11748_41600.n5 VSS 0.1179f
C2361 a_11748_41600.n6 VSS 0.13178f
C2362 a_11748_41600.n7 VSS 0.40451f
C2363 a_11748_41600.t6 VSS 0.14207f
C2364 a_65000_32348.t1 VSS 0.40381f
C2365 a_65000_32348.t0 VSS 0.1108f
C2366 a_65000_32348.n0 VSS 0.62359f
C2367 a_65000_32348.n1 VSS 1.90643f
C2368 a_65000_32348.n2 VSS 0.20818f
C2369 a_65000_32348.t2 VSS 0.40381f
C2370 a_66600_32348.t0 VSS 0.44843f
C2371 a_66600_32348.t2 VSS 0.12423f
C2372 a_66600_32348.n0 VSS 0.69915f
C2373 a_66600_32348.n1 VSS 2.1374f
C2374 a_66600_32348.n2 VSS 0.2334f
C2375 a_66600_32348.t1 VSS 0.44843f
C2376 a_65148_38800.t2 VSS 0.18579f
C2377 a_65148_38800.t1 VSS 0.18579f
C2378 a_65148_38800.n0 VSS 0.49537f
C2379 a_65148_38800.n1 VSS 0.14138f
C2380 a_65148_38800.t0 VSS 0.72279f
C2381 a_65148_38800.n2 VSS 0.12665f
C2382 a_65148_38800.t5 VSS 0.18727f
C2383 a_65148_38800.t4 VSS 0.18727f
C2384 a_65148_38800.n3 VSS 0.46086f
C2385 a_65148_38800.t7 VSS 0.17926f
C2386 a_65148_38800.t6 VSS 0.17926f
C2387 a_65148_38800.n4 VSS 0.46086f
C2388 a_65148_38800.n5 VSS 0.96523f
C2389 a_65148_38800.n6 VSS 0.42641f
C2390 a_65148_38800.n7 VSS 0.12487f
C2391 a_65148_38800.t3 VSS 0.72456f
C2392 a_n1000_22678.t0 VSS 0.43066f
C2393 a_n1000_22678.t2 VSS 0.11274f
C2394 a_n1000_22678.n0 VSS 0.61981f
C2395 a_n1000_22678.n1 VSS 1.98011f
C2396 a_n1000_22678.n2 VSS 0.20692f
C2397 a_n1000_22678.t1 VSS 0.43066f
C2398 a_600_22678.t1 VSS 0.47347f
C2399 a_600_22678.t0 VSS 0.12618f
C2400 a_600_22678.n0 VSS 0.69373f
C2401 a_600_22678.n1 VSS 2.21625f
C2402 a_600_22678.n2 VSS 0.23159f
C2403 a_600_22678.t2 VSS 0.47347f
C2404 a_n852_28800.t2 VSS 0.17014f
C2405 a_n852_28800.t1 VSS 0.17014f
C2406 a_n852_28800.n0 VSS 0.49564f
C2407 a_n852_28800.n1 VSS 0.14146f
C2408 a_n852_28800.t0 VSS 0.70725f
C2409 a_n852_28800.n2 VSS 0.12671f
C2410 a_n852_28800.t5 VSS 0.18675f
C2411 a_n852_28800.t4 VSS 0.18675f
C2412 a_n852_28800.n3 VSS 0.46111f
C2413 a_n852_28800.t7 VSS 0.17892f
C2414 a_n852_28800.t6 VSS 0.17892f
C2415 a_n852_28800.n4 VSS 0.46111f
C2416 a_n852_28800.n5 VSS 0.96575f
C2417 a_n852_28800.n6 VSS 0.42664f
C2418 a_n852_28800.n7 VSS 0.12494f
C2419 a_n852_28800.t3 VSS 0.70902f
C2420 a_65148_29400.t2 VSS 0.20009f
C2421 a_65148_29400.t1 VSS 0.20009f
C2422 a_65148_29400.n0 VSS 0.54754f
C2423 a_65148_29400.n1 VSS 0.15627f
C2424 a_65148_29400.t0 VSS 0.79359f
C2425 a_65148_29400.n2 VSS 0.13999f
C2426 a_65148_29400.t4 VSS 0.14123f
C2427 a_65148_29400.t5 VSS 0.14123f
C2428 a_65148_29400.n3 VSS 0.5094f
C2429 a_65148_29400.t6 VSS 0.14333f
C2430 a_65148_29400.t7 VSS 0.14333f
C2431 a_65148_29400.n4 VSS 0.5094f
C2432 a_65148_29400.n5 VSS 1.06689f
C2433 a_65148_29400.n6 VSS 0.47132f
C2434 a_65148_29400.n7 VSS 0.13803f
C2435 a_65148_29400.t3 VSS 0.79555f
C2436 a_72404_31500.t0 VSS 0.17833f
C2437 a_72404_31500.t4 VSS 0.09871f
C2438 a_72404_31500.n0 VSS 0.54876f
C2439 a_72404_31500.n1 VSS 1.66326f
C2440 a_72404_31500.t2 VSS 0.19463f
C2441 a_72404_31500.t3 VSS 0.19469f
C2442 a_72404_31500.n2 VSS 0.1374f
C2443 a_72404_31500.n3 VSS 0.52932f
C2444 a_72404_31500.n4 VSS 0.1374f
C2445 a_72404_31500.t1 VSS 0.17827f
C2446 a_75604_31500.t1 VSS 0.22573f
C2447 a_75604_31500.t0 VSS 0.10869f
C2448 a_75604_31500.n0 VSS 0.46491f
C2449 a_75604_31500.n1 VSS 1.75239f
C2450 a_75604_31500.t3 VSS 0.20322f
C2451 a_75604_31500.t4 VSS 0.20328f
C2452 a_75604_31500.n2 VSS 0.15993f
C2453 a_75604_31500.n3 VSS 0.66558f
C2454 a_75604_31500.n4 VSS 0.15993f
C2455 a_75604_31500.t2 VSS 0.22566f
C2456 a_72548_31500.t4 VSS 0.07418f
C2457 a_72548_31500.t3 VSS 0.07418f
C2458 a_72548_31500.n0 VSS 0.21494f
C2459 a_72548_31500.n1 VSS 0.12482f
C2460 a_72548_31500.t7 VSS 0.08269f
C2461 a_72548_31500.t6 VSS 0.08269f
C2462 a_72548_31500.n2 VSS 0.33204f
C2463 a_72548_31500.t0 VSS 0.08274f
C2464 a_72548_31500.t1 VSS 0.08274f
C2465 a_72548_31500.n3 VSS 0.33204f
C2466 a_72548_31500.n4 VSS 2.92442f
C2467 a_72548_31500.t2 VSS 0.2986f
C2468 a_72548_31500.n5 VSS 0.11305f
C2469 a_72548_31500.n6 VSS 0.29793f
C2470 a_72548_31500.n7 VSS 0.11128f
C2471 a_72548_31500.t5 VSS 0.30037f
C2472 a_74148_31500.t6 VSS 0.1035f
C2473 a_74148_31500.t7 VSS 0.1035f
C2474 a_74148_31500.n0 VSS 0.28247f
C2475 a_74148_31500.t5 VSS 0.09746f
C2476 a_74148_31500.t4 VSS 0.09746f
C2477 a_74148_31500.n1 VSS 0.29444f
C2478 a_74148_31500.n2 VSS 2.12933f
C2479 a_74148_31500.n3 VSS 0.52382f
C2480 a_74148_31500.t2 VSS 0.06565f
C2481 a_74148_31500.t1 VSS 0.06565f
C2482 a_74148_31500.n4 VSS 0.20875f
C2483 a_74148_31500.t0 VSS 0.28511f
C2484 a_74148_31500.n5 VSS 0.12149f
C2485 a_74148_31500.n6 VSS 0.12123f
C2486 a_74148_31500.n7 VSS 0.10672f
C2487 a_74148_31500.t3 VSS 0.28339f
C2488 a_80148_31500.t4 VSS 0.10488f
C2489 a_80148_31500.t3 VSS 0.10488f
C2490 a_80148_31500.n0 VSS 0.28368f
C2491 a_80148_31500.n1 VSS 0.09242f
C2492 a_80148_31500.t2 VSS 0.4107f
C2493 a_80148_31500.n2 VSS 0.08268f
C2494 a_80148_31500.t7 VSS 0.07095f
C2495 a_80148_31500.t6 VSS 0.07095f
C2496 a_80148_31500.n3 VSS 0.17413f
C2497 a_80148_31500.t1 VSS 0.06639f
C2498 a_80148_31500.t0 VSS 0.06639f
C2499 a_80148_31500.n4 VSS 0.17413f
C2500 a_80148_31500.n5 VSS 0.75464f
C2501 a_80148_31500.n6 VSS 0.40413f
C2502 a_80148_31500.n7 VSS 0.08148f
C2503 a_80148_31500.t5 VSS 0.4119f
C2504 a_n852_19400.t4 VSS 0.18447f
C2505 a_n852_19400.t3 VSS 0.18447f
C2506 a_n852_19400.n0 VSS 0.5479f
C2507 a_n852_19400.n1 VSS 0.15638f
C2508 a_n852_19400.t2 VSS 0.77818f
C2509 a_n852_19400.n2 VSS 0.14008f
C2510 a_n852_19400.t6 VSS 0.16971f
C2511 a_n852_19400.t7 VSS 0.16971f
C2512 a_n852_19400.n3 VSS 0.50974f
C2513 a_n852_19400.t0 VSS 0.17261f
C2514 a_n852_19400.t1 VSS 0.17261f
C2515 a_n852_19400.n4 VSS 0.50974f
C2516 a_n852_19400.n5 VSS 1.06759f
C2517 a_n852_19400.n6 VSS 0.47163f
C2518 a_n852_19400.n7 VSS 0.13812f
C2519 a_n852_19400.t5 VSS 0.78013f
C2520 a_n6716_3500.t0 VSS 0.543f
C2521 a_n6716_3500.t1 VSS 1.11245f
C2522 a_n6572_3500.t1 VSS 0.53009f
C2523 a_n6572_3500.t4 VSS 0.11763f
C2524 a_n6572_3500.t5 VSS 0.11768f
C2525 a_n6572_3500.n0 VSS 0.18549f
C2526 a_n6572_3500.t3 VSS 0.36985f
C2527 a_n6572_3500.t0 VSS 0.15622f
C2528 a_n6572_3500.n1 VSS 1.39633f
C2529 a_n6572_3500.n2 VSS 0.64607f
C2530 a_n6572_3500.n3 VSS 0.84861f
C2531 a_n6572_3500.n4 VSS 2.74162f
C2532 a_n6572_3500.n5 VSS 0.25248f
C2533 a_n6572_3500.t2 VSS 0.53018f
C2534 a_n3600_5641.t1 VSS 0.49714f
C2535 a_n3600_5641.t3 VSS 0.11508f
C2536 a_n3600_5641.t4 VSS 0.11503f
C2537 a_n3600_5641.n0 VSS 0.18273f
C2538 a_n3600_5641.t5 VSS 0.3653f
C2539 a_n3600_5641.t0 VSS 0.1539f
C2540 a_n3600_5641.n1 VSS 1.37555f
C2541 a_n3600_5641.n2 VSS 0.55474f
C2542 a_n3600_5641.n3 VSS 1.07214f
C2543 a_n3600_5641.n4 VSS 2.44613f
C2544 a_n3600_5641.n5 VSS 0.28121f
C2545 a_n3600_5641.t2 VSS 0.49705f
C2546 a_n1900_5958.t0 VSS 0.5683f
C2547 a_n1900_5958.t1 VSS 1.16128f
C2548 a_484_3500.t0 VSS 0.57067f
C2549 a_484_3500.t1 VSS 1.16586f
C2550 a_5300_5958.t1 VSS 0.53942f
C2551 a_5300_5958.t0 VSS 1.11788f
C2552 a_n5052_2600.t2 VSS 0.12119f
C2553 a_n5052_2600.t1 VSS 0.04306f
C2554 a_n5052_2600.t0 VSS 0.04303f
C2555 a_n5052_2600.n0 VSS 0.10737f
C2556 a_n5052_2600.t7 VSS 0.04419f
C2557 a_n5052_2600.t6 VSS 0.04422f
C2558 a_n5052_2600.n1 VSS 0.10737f
C2559 a_n5052_2600.n2 VSS 0.98516f
C2560 a_n5052_2600.t4 VSS 0.03011f
C2561 a_n5052_2600.t3 VSS 0.03011f
C2562 a_n5052_2600.n3 VSS 0.09122f
C2563 a_n5052_2600.n4 VSS 0.46257f
C2564 a_n5052_2600.t5 VSS 0.12119f
C2565 a_n5052_n1000.t5 VSS 0.15561f
C2566 a_n5052_n1000.t4 VSS 0.15561f
C2567 a_n5052_n1000.t3 VSS 0.15561f
C2568 a_n5052_n1000.n0 VSS 0.45893f
C2569 a_n5052_n1000.n1 VSS 0.14951f
C2570 a_n5052_n1000.t2 VSS 0.65016f
C2571 a_n5052_n1000.n2 VSS 0.13501f
C2572 a_n5052_n1000.t1 VSS 0.14185f
C2573 a_n5052_n1000.t0 VSS 0.14185f
C2574 a_n5052_n1000.n3 VSS 0.50742f
C2575 a_n5052_n1000.t7 VSS 0.16764f
C2576 a_n5052_n1000.t8 VSS 0.16764f
C2577 a_n5052_n1000.n4 VSS 0.50742f
C2578 a_n5052_n1000.n5 VSS 1.21852f
C2579 a_n5052_n1000.n6 VSS 0.49183f
C2580 a_n5052_n1000.n7 VSS 0.11815f
C2581 a_n5052_n1000.n8 VSS 0.4607f
C2582 a_n5052_n1000.t6 VSS 0.15606f
C2583 a_2148_n500.t4 VSS 0.10871f
C2584 a_2148_n500.t3 VSS 0.10871f
C2585 a_2148_n500.t2 VSS 0.10871f
C2586 a_2148_n500.n0 VSS 0.28658f
C2587 a_2148_n500.n1 VSS 0.09336f
C2588 a_2148_n500.t1 VSS 0.4177f
C2589 a_2148_n500.n2 VSS 0.08431f
C2590 a_2148_n500.t7 VSS 0.08272f
C2591 a_2148_n500.t6 VSS 0.08272f
C2592 a_2148_n500.n3 VSS 0.17591f
C2593 a_2148_n500.t0 VSS 0.08338f
C2594 a_2148_n500.t8 VSS 0.08338f
C2595 a_2148_n500.n4 VSS 0.17591f
C2596 a_2148_n500.n5 VSS 0.81634f
C2597 a_2148_n500.n6 VSS 0.37461f
C2598 a_2148_n500.n7 VSS 0.07378f
C2599 a_2148_n500.n8 VSS 0.28768f
C2600 a_2148_n500.t5 VSS 0.10916f
C2601 a_n10800_n12572.n0 VSS 0.74217f
C2602 a_n10800_n12572.t1 VSS 0.12063f
C2603 a_n10800_n12572.n1 VSS 1.77193f
C2604 a_n10800_n12572.t0 VSS 0.16741f
C2605 a_n7300_n12700.t0 VSS 1.02298f
C2606 a_n7300_n12700.t4 VSS 0.97775f
C2607 a_n7300_n12700.t3 VSS 0.97215f
C2608 a_n7300_n12700.n0 VSS 0.54148f
C2609 a_n7300_n12700.t2 VSS 0.1493f
C2610 a_n7300_n12700.n1 VSS 2.1793f
C2611 a_n7300_n12700.n2 VSS 0.35701f
C2612 a_n7300_n12700.t1 VSS 1.01737f
C2613 a_n6400_n12652.t2 VSS 0.31174f
C2614 a_n6400_n12652.t4 VSS 0.26683f
C2615 a_n6400_n12652.t3 VSS 0.26683f
C2616 a_n6400_n12652.n0 VSS 0.82091f
C2617 a_n6400_n12652.t0 VSS 0.16832f
C2618 a_n6400_n12652.n1 VSS 2.87005f
C2619 a_n6400_n12652.n2 VSS 0.94209f
C2620 a_n6400_n12652.t1 VSS 0.31174f
C2621 a_n10800_n14372.n0 VSS 0.8249f
C2622 a_n10800_n14372.t1 VSS 0.12987f
C2623 a_n10800_n14372.n1 VSS 1.96946f
C2624 a_n10800_n14372.t0 VSS 0.18155f
C2625 a_n7300_n14500.t0 VSS 1.05346f
C2626 a_n7300_n14500.t4 VSS 1.01146f
C2627 a_n7300_n14500.t3 VSS 1.0057f
C2628 a_n7300_n14500.n0 VSS 0.55746f
C2629 a_n7300_n14500.t2 VSS 0.15371f
C2630 a_n7300_n14500.n1 VSS 2.24362f
C2631 a_n7300_n14500.n2 VSS 0.36754f
C2632 a_n7300_n14500.t1 VSS 1.04768f
C2633 a_n6400_n14452.t2 VSS 0.31383f
C2634 a_n6400_n14452.t4 VSS 0.27216f
C2635 a_n6400_n14452.t3 VSS 0.27216f
C2636 a_n6400_n14452.n0 VSS 0.81591f
C2637 a_n6400_n14452.t0 VSS 0.16729f
C2638 a_n6400_n14452.n1 VSS 2.85257f
C2639 a_n6400_n14452.n2 VSS 0.93635f
C2640 a_n6400_n14452.t1 VSS 0.31383f
C2641 a_n10800_n16172.n0 VSS 0.8249f
C2642 a_n10800_n16172.t1 VSS 0.12987f
C2643 a_n10800_n16172.n1 VSS 1.96946f
C2644 a_n10800_n16172.t0 VSS 0.18155f
C2645 a_n7300_n16300.t1 VSS 1.05346f
C2646 a_n7300_n16300.t3 VSS 1.01146f
C2647 a_n7300_n16300.t4 VSS 1.0057f
C2648 a_n7300_n16300.n0 VSS 0.55746f
C2649 a_n7300_n16300.t0 VSS 0.15371f
C2650 a_n7300_n16300.n1 VSS 2.24362f
C2651 a_n7300_n16300.n2 VSS 0.36754f
C2652 a_n7300_n16300.t2 VSS 1.04768f
C2653 a_n6400_n16252.t1 VSS 0.31383f
C2654 a_n6400_n16252.t2 VSS 0.27216f
C2655 a_n6400_n16252.t3 VSS 0.27216f
C2656 a_n6400_n16252.n0 VSS 0.81591f
C2657 a_n6400_n16252.t4 VSS 0.16729f
C2658 a_n6400_n16252.n1 VSS 2.85257f
C2659 a_n6400_n16252.n2 VSS 0.93635f
C2660 a_n6400_n16252.t0 VSS 0.31383f
C2661 a_n10800_n17972.n0 VSS 0.8249f
C2662 a_n10800_n17972.t1 VSS 0.12987f
C2663 a_n10800_n17972.n1 VSS 1.96946f
C2664 a_n10800_n17972.t0 VSS 0.18155f
C2665 a_n7300_n18100.t0 VSS 1.05346f
C2666 a_n7300_n18100.t4 VSS 1.01146f
C2667 a_n7300_n18100.t3 VSS 1.0057f
C2668 a_n7300_n18100.n0 VSS 0.55746f
C2669 a_n7300_n18100.t2 VSS 0.15371f
C2670 a_n7300_n18100.n1 VSS 2.24362f
C2671 a_n7300_n18100.n2 VSS 0.36754f
C2672 a_n7300_n18100.t1 VSS 1.04768f
C2673 a_n6400_n18052.t1 VSS 0.31383f
C2674 a_n6400_n18052.t4 VSS 0.27216f
C2675 a_n6400_n18052.t3 VSS 0.27216f
C2676 a_n6400_n18052.n0 VSS 0.81591f
C2677 a_n6400_n18052.t2 VSS 0.16729f
C2678 a_n6400_n18052.n1 VSS 2.85257f
C2679 a_n6400_n18052.n2 VSS 0.93635f
C2680 a_n6400_n18052.t0 VSS 0.31383f
C2681 a_n10800_n19772.n0 VSS 0.8249f
C2682 a_n10800_n19772.t1 VSS 0.12987f
C2683 a_n10800_n19772.n1 VSS 1.96946f
C2684 a_n10800_n19772.t0 VSS 0.18155f
C2685 a_n7300_n19900.t1 VSS 1.05359f
C2686 a_n7300_n19900.t3 VSS 1.01158f
C2687 a_n7300_n19900.t4 VSS 1.00582f
C2688 a_n7300_n19900.n0 VSS 0.55754f
C2689 a_n7300_n19900.t0 VSS 0.15373f
C2690 a_n7300_n19900.n1 VSS 2.24392f
C2691 a_n7300_n19900.n2 VSS 0.36759f
C2692 a_n7300_n19900.t2 VSS 1.0478f
C2693 a_n6400_n19852.t2 VSS 0.31383f
C2694 a_n6400_n19852.t3 VSS 0.27216f
C2695 a_n6400_n19852.t4 VSS 0.27216f
C2696 a_n6400_n19852.n0 VSS 0.81591f
C2697 a_n6400_n19852.t0 VSS 0.16729f
C2698 a_n6400_n19852.n1 VSS 2.85257f
C2699 a_n6400_n19852.n2 VSS 0.93635f
C2700 a_n6400_n19852.t1 VSS 0.31383f
C2701 a_n10800_n21572.n0 VSS 0.82349f
C2702 a_n10800_n21572.t1 VSS 0.12929f
C2703 a_n10800_n21572.n1 VSS 1.96608f
C2704 a_n10800_n21572.t0 VSS 0.18086f
C2705 a_n7157_n21700.t2 VSS 1.01242f
C2706 a_n7157_n21700.t1 VSS 1.00665f
C2707 a_n7157_n21700.n0 VSS 0.5581f
C2708 a_n7157_n21700.t0 VSS 0.15048f
C2709 a_n7157_n21700.n1 VSS 2.16743f
C2710 a_n7157_n21700.t4 VSS 1.04788f
C2711 a_n7157_n21700.n2 VSS 0.36796f
C2712 a_n7157_n21700.t3 VSS 1.05367f
C2713 a_n6400_n21652.t2 VSS 0.27309f
C2714 a_n6400_n21652.t1 VSS 0.16442f
C2715 a_n6400_n21652.t3 VSS 0.31401f
C2716 a_n6400_n21652.t4 VSS 0.31401f
C2717 a_n6400_n21652.n0 VSS 0.94109f
C2718 a_n6400_n21652.n1 VSS 2.78096f
C2719 a_n6400_n21652.n2 VSS 0.82003f
C2720 a_n6400_n21652.t0 VSS 0.27309f
C2721 a_n10800_n23372.n0 VSS 0.78687f
C2722 a_n10800_n23372.t1 VSS 0.12249f
C2723 a_n10800_n23372.n1 VSS 1.87864f
C2724 a_n10800_n23372.t0 VSS 0.17169f
C2725 a_n7157_n23500.t2 VSS 0.94316f
C2726 a_n7157_n23500.t1 VSS 0.9378f
C2727 a_n7157_n23500.n0 VSS 0.51899f
C2728 a_n7157_n23500.t0 VSS 0.13994f
C2729 a_n7157_n23500.n1 VSS 2.01556f
C2730 a_n7157_n23500.t4 VSS 0.97513f
C2731 a_n7157_n23500.n2 VSS 0.34218f
C2732 a_n7157_n23500.t3 VSS 0.98051f
C2733 a_n6400_n23452.t1 VSS 0.26779f
C2734 a_n6400_n23452.t2 VSS 0.16253f
C2735 a_n6400_n23452.t4 VSS 0.30483f
C2736 a_n6400_n23452.t3 VSS 0.30483f
C2737 a_n6400_n23452.n0 VSS 0.93029f
C2738 a_n6400_n23452.n1 VSS 2.74905f
C2739 a_n6400_n23452.n2 VSS 0.81062f
C2740 a_n6400_n23452.t0 VSS 0.26779f
C2741 VSS.t409 VSS 0.08725f
C2742 VSS.t401 VSS 0.08725f
C2743 VSS.t407 VSS 0.08725f
C2744 VSS.t399 VSS 0.08892f
C2745 VSS.t403 VSS 0.08725f
C2746 VSS.t405 VSS 0.08725f
C2747 VSS.t420 VSS 0.12009f
C2748 VSS.t422 VSS 0.11783f
C2749 VSS.t416 VSS 0.11783f
C2750 VSS.t418 VSS 0.12009f
C2751 VSS.t412 VSS 0.11783f
C2752 VSS.t414 VSS 0.11783f
C2753 VSS.t424 VSS 0.11783f
C2754 VSS.t426 VSS 0.11783f
C2755 VSS.t552 VSS 0.20079f
C2756 VSS.t554 VSS 0.19701f
C2757 VSS.t197 VSS 0.19701f
C2758 VSS.t199 VSS 0.19701f
C2759 VSS.t539 VSS 0.14261f
C2760 VSS.t537 VSS 0.13993f
C2761 VSS.t243 VSS 0.08291f
C2762 VSS.t249 VSS 0.08291f
C2763 VSS.t241 VSS 0.08291f
C2764 VSS.t239 VSS 0.0845f
C2765 VSS.t247 VSS 0.08291f
C2766 VSS.t245 VSS 0.08291f
C2767 VSS.t530 VSS 0.13993f
C2768 VSS.t532 VSS 0.14261f
C2769 VSS.t534 VSS 0.13993f
C2770 VSS.t533 VSS 0.13993f
C2771 VSS.t535 VSS 0.13993f
C2772 VSS.t536 VSS 0.13993f
C2773 VSS.t185 VSS 0.16381f
C2774 VSS.t183 VSS 0.16381f
C2775 VSS.t171 VSS 0.20324f
C2776 VSS.t173 VSS 0.20324f
C2777 VSS.t175 VSS 0.20324f
C2778 VSS.t169 VSS 0.20714f
C2779 VSS.t354 VSS 0.11836f
C2780 VSS.t356 VSS 0.11614f
C2781 VSS.t368 VSS 0.11614f
C2782 VSS.t370 VSS 0.11836f
C2783 VSS.t364 VSS 0.11614f
C2784 VSS.t366 VSS 0.11614f
C2785 VSS.t358 VSS 0.11614f
C2786 VSS.t360 VSS 0.11614f
C2787 VSS.t430 VSS 0.09218f
C2788 VSS.t432 VSS 0.09045f
C2789 VSS.t350 VSS 0.09045f
C2790 VSS.t352 VSS 0.09045f
C2791 VSS.t434 VSS 0.09045f
C2792 VSS.t348 VSS 0.09045f
C2793 VSS.t282 VSS 0.08892f
C2794 VSS.t284 VSS 0.08725f
C2795 VSS.t286 VSS 0.08725f
C2796 VSS.t445 VSS 0.08725f
C2797 VSS.t447 VSS 0.08725f
C2798 VSS.t449 VSS 0.08725f
C2799 VSS.t375 VSS 0.12009f
C2800 VSS.t377 VSS 0.11783f
C2801 VSS.t379 VSS 0.11783f
C2802 VSS.t288 VSS 0.11783f
C2803 VSS.t290 VSS 0.11783f
C2804 VSS.t292 VSS 0.11783f
C2805 VSS.t294 VSS 0.11783f
C2806 VSS.t230 VSS 0.12009f
C2807 VSS.t219 VSS 0.19701f
C2808 VSS.t543 VSS 0.20079f
C2809 VSS.t215 VSS 0.19701f
C2810 VSS.t217 VSS 0.19701f
C2811 VSS.t344 VSS 0.14261f
C2812 VSS.t342 VSS 0.13993f
C2813 VSS.t340 VSS 0.13993f
C2814 VSS.t330 VSS 0.13993f
C2815 VSS.t338 VSS 0.13993f
C2816 VSS.t336 VSS 0.13993f
C2817 VSS.t480 VSS 0.0845f
C2818 VSS.t479 VSS 0.08291f
C2819 VSS.t478 VSS 0.08291f
C2820 VSS.t475 VSS 0.08291f
C2821 VSS.t477 VSS 0.08291f
C2822 VSS.t476 VSS 0.08291f
C2823 VSS.t334 VSS 0.13993f
C2824 VSS.t332 VSS 0.14261f
C2825 VSS.t84 VSS 0.16381f
C2826 VSS.t82 VSS 0.16381f
C2827 VSS.t277 VSS 0.20324f
C2828 VSS.t279 VSS 0.20324f
C2829 VSS.t546 VSS 0.20714f
C2830 VSS.t548 VSS 0.20324f
C2831 VSS.t296 VSS 0.11836f
C2832 VSS.t298 VSS 0.11614f
C2833 VSS.t300 VSS 0.11614f
C2834 VSS.t302 VSS 0.11614f
C2835 VSS.t104 VSS 0.11614f
C2836 VSS.t106 VSS 0.11614f
C2837 VSS.t108 VSS 0.11614f
C2838 VSS.t110 VSS 0.11836f
C2839 VSS.t436 VSS 0.09045f
C2840 VSS.t438 VSS 0.09045f
C2841 VSS.t440 VSS 0.09045f
C2842 VSS.t442 VSS 0.09045f
C2843 VSS.t232 VSS 0.09045f
C2844 VSS.t234 VSS 0.09218f
C2845 VSS.t515 VSS 0.13813f
C2846 VSS.t453 VSS 0.13813f
C2847 VSS.t521 VSS 0.14078f
C2848 VSS.t486 VSS 0.0866f
C2849 VSS.t487 VSS 0.08665f
C2850 VSS.t209 VSS 0.07345f
C2851 VSS.t207 VSS 0.07207f
C2852 VSS.t205 VSS 0.07207f
C2853 VSS.t203 VSS 0.07345f
C2854 VSS.t130 VSS 0.06826f
C2855 VSS.t124 VSS 0.06698f
C2856 VSS.t128 VSS 0.06698f
C2857 VSS.t126 VSS 0.06826f
C2858 VSS.t306 VSS 0.16234f
C2859 VSS.t187 VSS 0.16234f
C2860 VSS.t55 VSS 0.04055f
C2861 VSS.t53 VSS 0.03978f
C2862 VSS.t41 VSS 0.03978f
C2863 VSS.t39 VSS 0.04055f
C2864 VSS.t47 VSS 0.03978f
C2865 VSS.t43 VSS 0.03978f
C2866 VSS.t49 VSS 0.03978f
C2867 VSS.t45 VSS 0.03978f
C2868 VSS.t523 VSS 0.12931f
C2869 VSS.t525 VSS 0.13179f
C2870 VSS.t517 VSS 0.12931f
C2871 VSS.t18 VSS 0.16084f
C2872 VSS.t20 VSS 0.16084f
C2873 VSS.t65 VSS 0.03978f
C2874 VSS.t67 VSS 0.03978f
C2875 VSS.t58 VSS 0.03978f
C2876 VSS.t51 VSS 0.04055f
C2877 VSS.t56 VSS 0.03978f
C2878 VSS.t60 VSS 0.03978f
C2879 VSS.t63 VSS 0.03978f
C2880 VSS.t61 VSS 0.03978f
C2881 VSS.t189 VSS 0.08741f
C2882 VSS.t372 VSS 0.08746f
C2883 VSS.t224 VSS 0.08484f
C2884 VSS.t226 VSS 0.08489f
C2885 VSS.t451 VSS 0.16193f
C2886 VSS.t459 VSS 0.16193f
C2887 VSS.t527 VSS 0.12632f
C2888 VSS.t466 VSS 0.12632f
C2889 VSS.t388 VSS 0.12874f
C2890 VSS.t253 VSS 0.03799f
C2891 VSS.t263 VSS 0.03799f
C2892 VSS.t275 VSS 0.03799f
C2893 VSS.t274 VSS 0.03799f
C2894 VSS.t271 VSS 0.03799f
C2895 VSS.t269 VSS 0.03872f
C2896 VSS.t273 VSS 0.03799f
C2897 VSS.t272 VSS 0.03799f
C2898 VSS.t23 VSS 0.15757f
C2899 VSS.t25 VSS 0.15757f
C2900 VSS.t261 VSS 0.03872f
C2901 VSS.t267 VSS 0.03799f
C2902 VSS.t258 VSS 0.03799f
C2903 VSS.t256 VSS 0.03872f
C2904 VSS.t259 VSS 0.03799f
C2905 VSS.t254 VSS 0.03799f
C2906 VSS.t265 VSS 0.03799f
C2907 VSS.t264 VSS 0.03799f
C2908 VSS.t562 VSS 0.07434f
C2909 VSS.t560 VSS 0.07294f
C2910 VSS.t558 VSS 0.07294f
C2911 VSS.t556 VSS 0.07434f
C2912 VSS.t461 VSS 0.08719f
C2913 VSS.t463 VSS 0.08724f
C2914 VSS.t492 VSS 0.07495f
C2915 VSS.t494 VSS 0.07354f
C2916 VSS.t493 VSS 0.07354f
C2917 VSS.t490 VSS 0.07495f
C2918 VSS.t468 VSS 0.13279f
C2919 VSS.t457 VSS 0.13279f
C2920 VSS.t519 VSS 0.13533f
C2921 VSS.t396 VSS 0.05093f
C2922 VSS.t528 VSS 0.05439f
C2923 VSS.t529 VSS 0.05484f
C2924 VSS.t15 VSS 0.05484f
C2925 VSS.t180 VSS 0.05484f
C2926 VSS.t186 VSS 0.05484f
C2927 VSS.t237 VSS 0.05312f
C2928 VSS.t499 VSS 0.03199f
C2929 VSS.t501 VSS 0.03245f
C2930 VSS.t505 VSS 0.03245f
C2931 VSS.t503 VSS 0.03199f
C2932 VSS.t163 VSS 0.03465f
C2933 VSS.t162 VSS 0.03424f
C2934 VSS.t160 VSS 0.03424f
C2935 VSS.t161 VSS 0.03465f
C2936 VSS.t509 VSS 0.03199f
C2937 VSS.t507 VSS 0.03245f
C2938 VSS.t513 VSS 0.03245f
C2939 VSS.t511 VSS 0.03199f
C2940 VSS.t115 VSS 0.01731f
C2941 VSS.t114 VSS 0.0179f
C2942 VSS.t116 VSS 0.0179f
C2943 VSS.t113 VSS 0.01731f
C2944 VSS.t144 VSS 0.02768f
C2945 VSS.t142 VSS 0.02808f
C2946 VSS.t140 VSS 0.02808f
C2947 VSS.t146 VSS 0.02768f
C2948 VSS.t4 VSS 0.01042f
C2949 VSS.t2 VSS 0.01078f
C2950 VSS.t8 VSS 0.01078f
C2951 VSS.t6 VSS 0.01042f
C2952 VSS.t80 VSS 0.05055f
C2953 VSS.t79 VSS 0.04996f
C2954 VSS.t70 VSS 0.04996f
C2955 VSS.t72 VSS 0.05055f
C2956 VSS.t78 VSS 0.05055f
C2957 VSS.t74 VSS 0.04996f
C2958 VSS.t76 VSS 0.04996f
C2959 VSS.t75 VSS 0.05055f
C2960 VSS.t159 VSS 0.03465f
C2961 VSS.t157 VSS 0.03424f
C2962 VSS.t155 VSS 0.03424f
C2963 VSS.t153 VSS 0.03465f
C2964 VSS.t324 VSS 0.03072f
C2965 VSS.t323 VSS 0.03072f
C2966 VSS.t325 VSS 0.03117f
C2967 VSS.t322 VSS 0.03072f
C2968 VSS.t317 VSS 0.03117f
C2969 VSS.t328 VSS 0.03117f
C2970 VSS.t327 VSS 0.03072f
C2971 VSS.t326 VSS 0.03072f
C2972 VSS.t312 VSS 0.03072f
C2973 VSS.t321 VSS 0.03117f
C2974 VDD.t372 VSS 0.79073f
C2975 VDD.t371 VSS 0.71166f
C2976 VDD.t508 VSS 0.71166f
C2977 VDD.t507 VSS 0.71166f
C2978 VDD.t512 VSS 0.71166f
C2979 VDD.t511 VSS 0.71166f
C2980 VDD.t7 VSS 0.71166f
C2981 VDD.t6 VSS 0.71166f
C2982 VDD.t108 VSS 0.71166f
C2983 VDD.t107 VSS 0.71166f
C2984 VDD.t128 VSS 0.71166f
C2985 VDD.t127 VSS 0.71166f
C2986 VDD.t194 VSS 0.71166f
C2987 VDD.t193 VSS 0.3999f
C2988 VDD.t192 VSS 0.08267f
C2989 VDD.t126 VSS 0.0845f
C2990 VDD.n0 VSS 0.08946f
C2991 VDD.t191 VSS 0.522f
C2992 VDD.t105 VSS 0.36139f
C2993 VDD.t106 VSS 0.0845f
C2994 VDD.t5 VSS 0.0845f
C2995 VDD.n1 VSS 0.08946f
C2996 VDD.t509 VSS 0.36139f
C2997 VDD.t510 VSS 0.0845f
C2998 VDD.t506 VSS 0.08403f
C2999 VDD.n2 VSS 0.08946f
C3000 VDD.t369 VSS 0.37442f
C3001 VDD.t370 VSS 0.0803f
C3002 VDD.n3 VSS 0.38747f
C3003 VDD.n4 VSS 0.06177f
C3004 VDD.n5 VSS 0.3705f
C3005 VDD.t505 VSS 0.36139f
C3006 VDD.n6 VSS 0.3705f
C3007 VDD.n7 VSS 0.06177f
C3008 VDD.n8 VSS 0.08946f
C3009 VDD.n9 VSS 0.06177f
C3010 VDD.n10 VSS 0.3705f
C3011 VDD.t4 VSS 0.36139f
C3012 VDD.n11 VSS 0.3705f
C3013 VDD.n12 VSS 0.06177f
C3014 VDD.n13 VSS 0.08946f
C3015 VDD.n14 VSS 0.06177f
C3016 VDD.n15 VSS 0.3705f
C3017 VDD.t125 VSS 0.36139f
C3018 VDD.n16 VSS 0.3705f
C3019 VDD.n17 VSS 0.06177f
C3020 VDD.n18 VSS 0.21691f
C3021 VDD.n19 VSS 1.4749f
C3022 VDD.n20 VSS 21.6752f
C3023 VDD.t138 VSS 0.06361f
C3024 VDD.t49 VSS 0.05586f
C3025 VDD.n21 VSS 0.34756f
C3026 VDD.t9 VSS 0.05777f
C3027 VDD.t31 VSS 0.05511f
C3028 VDD.n22 VSS 0.2998f
C3029 VDD.n23 VSS 1.22698f
C3030 VDD.t8 VSS 0.04212f
C3031 VDD.t470 VSS 0.03986f
C3032 VDD.n24 VSS 0.49957f
C3033 VDD.t196 VSS 0.04212f
C3034 VDD.t563 VSS 0.03986f
C3035 VDD.n25 VSS 0.23678f
C3036 VDD.n26 VSS 0.38716f
C3037 VDD.n27 VSS 0.77961f
C3038 VDD.t169 VSS 0.05685f
C3039 VDD.t137 VSS 0.04847f
C3040 VDD.n28 VSS 0.56014f
C3041 VDD.t168 VSS 0.04847f
C3042 VDD.n29 VSS 0.60609f
C3043 VDD.t136 VSS 0.04847f
C3044 VDD.n30 VSS 0.72007f
C3045 VDD.t365 VSS 1.57528f
C3046 VDD.t366 VSS 1.89033f
C3047 VDD.t367 VSS 1.89033f
C3048 VDD.t368 VSS 1.44726f
C3049 VDD.t68 VSS 0.03425f
C3050 VDD.t69 VSS 0.03775f
C3051 VDD.n31 VSS 0.22676f
C3052 VDD.t70 VSS 0.03775f
C3053 VDD.n32 VSS 0.11572f
C3054 VDD.t202 VSS 0.03265f
C3055 VDD.n33 VSS 0.1465f
C3056 VDD.t18 VSS 0.03265f
C3057 VDD.n34 VSS 0.24925f
C3058 VDD.t468 VSS 0.04046f
C3059 VDD.n35 VSS 0.21819f
C3060 VDD.t195 VSS 0.04046f
C3061 VDD.n36 VSS 0.21819f
C3062 VDD.t467 VSS 0.03265f
C3063 VDD.n37 VSS 0.17181f
C3064 VDD.n38 VSS 3.25969f
C3065 VDD.t139 VSS 0.05012f
C3066 VDD.t170 VSS 0.04771f
C3067 VDD.n39 VSS 0.51764f
C3068 VDD.t48 VSS 0.05012f
C3069 VDD.t197 VSS 0.04771f
C3070 VDD.n40 VSS 0.25649f
C3071 VDD.n41 VSS 1.54908f
C3072 VDD.n42 VSS 8.89756f
C3073 VDD.n43 VSS 6.68422f
C3074 VDD.n44 VSS 0.21775f
C3075 VDD.n45 VSS 0.10183f
C3076 VDD.n46 VSS 0.11625f
C3077 VDD.n47 VSS 0.1112f
C3078 VDD.t391 VSS 0.51891f
C3079 VDD.n48 VSS 0.1112f
C3080 VDD.n49 VSS 0.11625f
C3081 VDD.n50 VSS 0.11851f
C3082 VDD.n51 VSS 0.11625f
C3083 VDD.n52 VSS 0.1112f
C3084 VDD.n53 VSS 5.18915f
C3085 VDD.n54 VSS 0.31283f
C3086 VDD.t489 VSS 0.14826f
C3087 VDD.n55 VSS 0.1112f
C3088 VDD.n56 VSS 0.11625f
C3089 VDD.n57 VSS 0.11851f
C3090 VDD.n58 VSS 0.11625f
C3091 VDD.n59 VSS 0.1112f
C3092 VDD.t543 VSS 0.59305f
C3093 VDD.n60 VSS 0.1112f
C3094 VDD.n61 VSS 0.11625f
C3095 VDD.n62 VSS 0.11851f
C3096 VDD.n63 VSS 0.11625f
C3097 VDD.n64 VSS 0.1112f
C3098 VDD.t521 VSS 2.22392f
C3099 VDD.t123 VSS 0.44478f
C3100 VDD.n65 VSS 0.50198f
C3101 VDD.n66 VSS 7.09482f
C3102 VDD.n67 VSS 0.1112f
C3103 VDD.n68 VSS 0.11625f
C3104 VDD.n69 VSS 0.09948f
C3105 VDD.n70 VSS 0.11625f
C3106 VDD.n71 VSS 0.1112f
C3107 VDD.n72 VSS 5.67493f
C3108 VDD.n73 VSS 3.97671f
C3109 VDD.t279 VSS 1.48261f
C3110 VDD.t281 VSS 0.59305f
C3111 VDD.t283 VSS 0.59305f
C3112 VDD.t285 VSS 0.59305f
C3113 VDD.t287 VSS 0.59305f
C3114 VDD.t109 VSS 0.59305f
C3115 VDD.t111 VSS 0.59305f
C3116 VDD.t113 VSS 2.22392f
C3117 VDD.t487 VSS 3.48415f
C3118 VDD.t485 VSS 0.51891f
C3119 VDD.n74 VSS 2.14979f
C3120 VDD.n75 VSS 0.1112f
C3121 VDD.n76 VSS 0.11625f
C3122 VDD.n77 VSS 0.32083f
C3123 VDD.n78 VSS 0.11851f
C3124 VDD.n79 VSS 0.11851f
C3125 VDD.n80 VSS 0.11625f
C3126 VDD.n81 VSS 0.1112f
C3127 VDD.n82 VSS 7.41307f
C3128 VDD.n83 VSS 5.18915f
C3129 VDD.n84 VSS 3.75893f
C3130 VDD.n85 VSS 0.31283f
C3131 VDD.n86 VSS 0.31283f
C3132 VDD.n87 VSS 0.49718f
C3133 VDD.t121 VSS 0.44478f
C3134 VDD.t549 VSS 0.59305f
C3135 VDD.t551 VSS 0.59305f
C3136 VDD.t553 VSS 0.44478f
C3137 VDD.t444 VSS 0.44478f
C3138 VDD.t446 VSS 0.59305f
C3139 VDD.t445 VSS 0.59305f
C3140 VDD.t448 VSS 0.59305f
C3141 VDD.t447 VSS 0.59305f
C3142 VDD.t450 VSS 0.59305f
C3143 VDD.t449 VSS 0.59305f
C3144 VDD.t491 VSS 0.44478f
C3145 VDD.t315 VSS 0.44478f
C3146 VDD.t311 VSS 0.59305f
C3147 VDD.t333 VSS 0.59305f
C3148 VDD.t335 VSS 0.51891f
C3149 VDD.t397 VSS 0.29652f
C3150 VDD.t337 VSS 0.29652f
C3151 VDD.t395 VSS 0.29652f
C3152 VDD.t325 VSS 0.29652f
C3153 VDD.t393 VSS 0.29652f
C3154 VDD.t339 VSS 0.29652f
C3155 VDD.t409 VSS 0.29652f
C3156 VDD.t341 VSS 0.29652f
C3157 VDD.t407 VSS 0.51891f
C3158 VDD.t405 VSS 0.59305f
C3159 VDD.t76 VSS 0.51891f
C3160 VDD.t539 VSS 0.29652f
C3161 VDD.t74 VSS 0.14826f
C3162 VDD.n88 VSS 0.22239f
C3163 VDD.n89 VSS 0.1112f
C3164 VDD.n90 VSS 0.11625f
C3165 VDD.n91 VSS 0.11851f
C3166 VDD.n92 VSS 0.11851f
C3167 VDD.n93 VSS 0.11851f
C3168 VDD.n94 VSS 0.11625f
C3169 VDD.n95 VSS 0.1112f
C3170 VDD.t541 VSS 0.59305f
C3171 VDD.t537 VSS 1.48261f
C3172 VDD.t50 VSS 2.37218f
C3173 VDD.t536 VSS 1.48261f
C3174 VDD.t535 VSS 0.59305f
C3175 VDD.t534 VSS 0.59305f
C3176 VDD.t120 VSS 0.44478f
C3177 VDD.n96 VSS 0.29652f
C3178 VDD.t119 VSS 0.44478f
C3179 VDD.t533 VSS 0.59305f
C3180 VDD.t532 VSS 0.59305f
C3181 VDD.t531 VSS 1.48261f
C3182 VDD.t52 VSS 2.37218f
C3183 VDD.t529 VSS 1.48261f
C3184 VDD.t555 VSS 0.29652f
C3185 VDD.t453 VSS 0.51891f
C3186 VDD.t451 VSS 0.59305f
C3187 VDD.t494 VSS 0.51891f
C3188 VDD.t317 VSS 0.29652f
C3189 VDD.t492 VSS 0.29652f
C3190 VDD.t319 VSS 0.29652f
C3191 VDD.t131 VSS 0.29652f
C3192 VDD.t321 VSS 0.29652f
C3193 VDD.t129 VSS 0.29652f
C3194 VDD.t327 VSS 0.29652f
C3195 VDD.t140 VSS 0.29652f
C3196 VDD.t329 VSS 0.51891f
C3197 VDD.t323 VSS 0.59305f
C3198 VDD.t313 VSS 0.59305f
C3199 VDD.t331 VSS 0.44478f
C3200 VDD.t296 VSS 0.44478f
C3201 VDD.t295 VSS 0.59305f
C3202 VDD.t291 VSS 0.59305f
C3203 VDD.t290 VSS 0.59305f
C3204 VDD.t289 VSS 0.59305f
C3205 VDD.t419 VSS 0.59305f
C3206 VDD.t418 VSS 0.59305f
C3207 VDD.t417 VSS 0.44478f
C3208 VDD.t515 VSS 0.44478f
C3209 VDD.t517 VSS 0.59305f
C3210 VDD.t519 VSS 0.59305f
C3211 VDD.t115 VSS 0.44478f
C3212 VDD.n97 VSS 0.49718f
C3213 VDD.t117 VSS 0.44478f
C3214 VDD.t525 VSS 0.59305f
C3215 VDD.t527 VSS 0.59305f
C3216 VDD.n98 VSS 0.1112f
C3217 VDD.n99 VSS 0.11625f
C3218 VDD.n100 VSS 0.11851f
C3219 VDD.n101 VSS 0.11851f
C3220 VDD.n102 VSS 0.11851f
C3221 VDD.n103 VSS 0.11625f
C3222 VDD.n104 VSS 0.1112f
C3223 VDD.n105 VSS 0.22239f
C3224 VDD.t547 VSS 2.22392f
C3225 VDD.n106 VSS 3.75893f
C3226 VDD.n107 VSS 0.31283f
C3227 VDD.n108 VSS 0.31283f
C3228 VDD.t389 VSS 3.48415f
C3229 VDD.n109 VSS 7.09482f
C3230 VDD.n110 VSS 7.41307f
C3231 VDD.n111 VSS 0.1112f
C3232 VDD.n112 VSS 0.11625f
C3233 VDD.n113 VSS 0.11851f
C3234 VDD.n114 VSS 0.11851f
C3235 VDD.n115 VSS 0.11851f
C3236 VDD.n116 VSS 0.11625f
C3237 VDD.n117 VSS 0.1112f
C3238 VDD.n118 VSS 2.14979f
C3239 VDD.t383 VSS 2.22392f
C3240 VDD.t385 VSS 0.59305f
C3241 VDD.t387 VSS 0.59305f
C3242 VDD.t375 VSS 0.59305f
C3243 VDD.t377 VSS 0.59305f
C3244 VDD.t379 VSS 0.59305f
C3245 VDD.t381 VSS 0.59305f
C3246 VDD.t373 VSS 1.48261f
C3247 VDD.n119 VSS 3.96215f
C3248 VDD.n120 VSS 5.66794f
C3249 VDD.n121 VSS 0.09443f
C3250 VDD.n122 VSS 0.11699f
C3251 VDD.t556 VSS 0.15546f
C3252 VDD.t548 VSS 0.15543f
C3253 VDD.n123 VSS 0.17169f
C3254 VDD.n124 VSS 0.19228f
C3255 VDD.n125 VSS 0.06693f
C3256 VDD.n126 VSS 0.0444f
C3257 VDD.t280 VSS 0.10503f
C3258 VDD.t282 VSS 0.1033f
C3259 VDD.n127 VSS 0.0694f
C3260 VDD.t112 VSS 0.1033f
C3261 VDD.t114 VSS 0.10503f
C3262 VDD.n128 VSS 0.06703f
C3263 VDD.t288 VSS 0.1033f
C3264 VDD.t110 VSS 0.1033f
C3265 VDD.n129 VSS 0.06651f
C3266 VDD.n130 VSS 0.03371f
C3267 VDD.t284 VSS 0.1033f
C3268 VDD.t286 VSS 0.1033f
C3269 VDD.n131 VSS 0.06651f
C3270 VDD.n132 VSS 0.16674f
C3271 VDD.n133 VSS 0.19721f
C3272 VDD.t486 VSS 0.1312f
C3273 VDD.t488 VSS 0.1312f
C3274 VDD.n134 VSS 0.19605f
C3275 VDD.n135 VSS 0.71648f
C3276 VDD.t522 VSS 0.15546f
C3277 VDD.t540 VSS 0.15543f
C3278 VDD.n136 VSS 0.17169f
C3279 VDD.n137 VSS 0.17726f
C3280 VDD.n138 VSS 0.33113f
C3281 VDD.t75 VSS 0.21609f
C3282 VDD.t77 VSS 0.21609f
C3283 VDD.n139 VSS 0.06651f
C3284 VDD.n140 VSS 0.19622f
C3285 VDD.t406 VSS 0.21609f
C3286 VDD.t408 VSS 0.21609f
C3287 VDD.n141 VSS 0.06651f
C3288 VDD.n142 VSS 0.01439f
C3289 VDD.t396 VSS 0.21609f
C3290 VDD.t398 VSS 0.21999f
C3291 VDD.n143 VSS 0.06703f
C3292 VDD.t410 VSS 0.21609f
C3293 VDD.t394 VSS 0.21609f
C3294 VDD.n144 VSS 0.06651f
C3295 VDD.n145 VSS 0.03089f
C3296 VDD.n146 VSS 0.07368f
C3297 VDD.n147 VSS 0.21306f
C3298 VDD.t342 VSS 0.15086f
C3299 VDD.t340 VSS 0.15079f
C3300 VDD.n148 VSS 0.06651f
C3301 VDD.n149 VSS 0.01875f
C3302 VDD.t312 VSS 0.15079f
C3303 VDD.t316 VSS 0.15455f
C3304 VDD.n150 VSS 0.06703f
C3305 VDD.t336 VSS 0.15079f
C3306 VDD.t334 VSS 0.15079f
C3307 VDD.n151 VSS 0.06651f
C3308 VDD.n152 VSS 0.03371f
C3309 VDD.t326 VSS 0.15079f
C3310 VDD.t338 VSS 0.15079f
C3311 VDD.n153 VSS 0.06651f
C3312 VDD.n154 VSS 0.01533f
C3313 VDD.n155 VSS 0.05002f
C3314 VDD.n156 VSS 0.09134f
C3315 VDD.n157 VSS 0.15641f
C3316 VDD.t122 VSS 0.17667f
C3317 VDD.t124 VSS 0.17664f
C3318 VDD.n158 VSS 0.11016f
C3319 VDD.t554 VSS 0.11771f
C3320 VDD.t552 VSS 0.11494f
C3321 VDD.n159 VSS 0.06651f
C3322 VDD.n160 VSS 0.1153f
C3323 VDD.t550 VSS 0.11494f
C3324 VDD.t546 VSS 0.11494f
C3325 VDD.n161 VSS 0.06651f
C3326 VDD.n162 VSS 0.01908f
C3327 VDD.t545 VSS 0.11494f
C3328 VDD.t544 VSS 0.11494f
C3329 VDD.n163 VSS 0.06651f
C3330 VDD.n164 VSS 0.01908f
C3331 VDD.t542 VSS 0.11494f
C3332 VDD.t538 VSS 0.11494f
C3333 VDD.n165 VSS 0.06651f
C3334 VDD.n166 VSS 0.01514f
C3335 VDD.n167 VSS 0.16559f
C3336 VDD.t51 VSS 0.10137f
C3337 VDD.n168 VSS 0.12776f
C3338 VDD.n169 VSS 0.13642f
C3339 VDD.n170 VSS 0.10637f
C3340 VDD.t118 VSS 0.17667f
C3341 VDD.t116 VSS 0.17664f
C3342 VDD.n171 VSS 0.11016f
C3343 VDD.t53 VSS 0.10137f
C3344 VDD.n172 VSS 0.15302f
C3345 VDD.t518 VSS 0.11494f
C3346 VDD.t516 VSS 0.11771f
C3347 VDD.n173 VSS 0.06703f
C3348 VDD.t524 VSS 0.11494f
C3349 VDD.t520 VSS 0.11494f
C3350 VDD.n174 VSS 0.06651f
C3351 VDD.n175 VSS 0.03371f
C3352 VDD.t526 VSS 0.11494f
C3353 VDD.t523 VSS 0.11494f
C3354 VDD.n176 VSS 0.06651f
C3355 VDD.n177 VSS 0.01908f
C3356 VDD.t530 VSS 0.11494f
C3357 VDD.t528 VSS 0.11494f
C3358 VDD.n178 VSS 0.06651f
C3359 VDD.n179 VSS 0.03649f
C3360 VDD.n180 VSS 0.24234f
C3361 VDD.n181 VSS 0.08437f
C3362 VDD.n182 VSS 0.11263f
C3363 VDD.t332 VSS 0.15455f
C3364 VDD.t314 VSS 0.15079f
C3365 VDD.n183 VSS 0.06651f
C3366 VDD.n184 VSS 0.0927f
C3367 VDD.t324 VSS 0.15079f
C3368 VDD.t330 VSS 0.15079f
C3369 VDD.n185 VSS 0.06651f
C3370 VDD.n186 VSS 0.01533f
C3371 VDD.t320 VSS 0.15079f
C3372 VDD.t318 VSS 0.15455f
C3373 VDD.n187 VSS 0.06703f
C3374 VDD.t328 VSS 0.15079f
C3375 VDD.t322 VSS 0.15079f
C3376 VDD.n188 VSS 0.06651f
C3377 VDD.n189 VSS 0.02995f
C3378 VDD.n191 VSS 0.21335f
C3379 VDD.t141 VSS 0.21364f
C3380 VDD.t130 VSS 0.20986f
C3381 VDD.n192 VSS 0.06651f
C3382 VDD.n193 VSS 0.08651f
C3383 VDD.t132 VSS 0.20986f
C3384 VDD.t493 VSS 0.20986f
C3385 VDD.n194 VSS 0.06651f
C3386 VDD.n195 VSS 0.01908f
C3387 VDD.t495 VSS 0.20986f
C3388 VDD.t452 VSS 0.20986f
C3389 VDD.n196 VSS 0.06651f
C3390 VDD.n197 VSS 0.01908f
C3391 VDD.t454 VSS 0.20986f
C3392 VDD.t490 VSS 0.20986f
C3393 VDD.n198 VSS 0.06651f
C3394 VDD.n199 VSS 0.19622f
C3395 VDD.n200 VSS 0.33864f
C3396 VDD.t390 VSS 0.13292f
C3397 VDD.t392 VSS 0.13292f
C3398 VDD.n201 VSS 0.19605f
C3399 VDD.n202 VSS 0.38261f
C3400 VDD.n203 VSS 0.18991f
C3401 VDD.t384 VSS 0.10177f
C3402 VDD.t386 VSS 0.1001f
C3403 VDD.n204 VSS 0.06651f
C3404 VDD.n205 VSS 0.16279f
C3405 VDD.t382 VSS 0.1001f
C3406 VDD.t374 VSS 0.10177f
C3407 VDD.n206 VSS 0.06703f
C3408 VDD.t378 VSS 0.1001f
C3409 VDD.t380 VSS 0.1001f
C3410 VDD.n207 VSS 0.06651f
C3411 VDD.n208 VSS 0.03371f
C3412 VDD.t388 VSS 0.1001f
C3413 VDD.t376 VSS 0.1001f
C3414 VDD.n209 VSS 0.06651f
C3415 VDD.n210 VSS 0.16674f
C3416 VDD.n211 VSS 0.24402f
C3417 VDD.n212 VSS 5.31984f
C3418 VDD.n213 VSS 0.23909f
C3419 VDD.n214 VSS 0.07959f
C3420 VDD.n215 VSS 0.11625f
C3421 VDD.n216 VSS 0.1112f
C3422 VDD.t471 VSS 0.74131f
C3423 VDD.n217 VSS 0.1112f
C3424 VDD.n218 VSS 0.11625f
C3425 VDD.n219 VSS 0.11851f
C3426 VDD.n220 VSS 0.11625f
C3427 VDD.n221 VSS 0.1112f
C3428 VDD.t72 VSS 2.81697f
C3429 VDD.n222 VSS 0.31283f
C3430 VDD.t303 VSS 0.44478f
C3431 VDD.n223 VSS 0.1112f
C3432 VDD.n224 VSS 0.11625f
C3433 VDD.n225 VSS 0.11851f
C3434 VDD.n226 VSS 0.11625f
C3435 VDD.n227 VSS 0.1112f
C3436 VDD.t561 VSS 0.74131f
C3437 VDD.n228 VSS 0.1112f
C3438 VDD.n229 VSS 0.11625f
C3439 VDD.n230 VSS 0.11851f
C3440 VDD.n231 VSS 0.11625f
C3441 VDD.n232 VSS 0.1112f
C3442 VDD.t90 VSS 0.44478f
C3443 VDD.n233 VSS 0.50198f
C3444 VDD.t36 VSS 0.74131f
C3445 VDD.n234 VSS 0.1112f
C3446 VDD.n235 VSS 0.11625f
C3447 VDD.n236 VSS 0.09948f
C3448 VDD.n237 VSS 0.11625f
C3449 VDD.n238 VSS 0.1112f
C3450 VDD.n239 VSS 5.67493f
C3451 VDD.n240 VSS 4.27323f
C3452 VDD.n241 VSS 1.77914f
C3453 VDD.t503 VSS 0.59305f
C3454 VDD.t459 VSS 0.59305f
C3455 VDD.t457 VSS 0.59305f
C3456 VDD.t463 VSS 2.81697f
C3457 VDD.t34 VSS 0.59305f
C3458 VDD.t38 VSS 0.59305f
C3459 VDD.t40 VSS 0.59305f
C3460 VDD.t42 VSS 0.59305f
C3461 VDD.t44 VSS 0.59305f
C3462 VDD.t32 VSS 0.59305f
C3463 VDD.t46 VSS 1.48261f
C3464 VDD.n242 VSS 2.57284f
C3465 VDD.t152 VSS 1.48261f
C3466 VDD.t154 VSS 0.59305f
C3467 VDD.t150 VSS 0.59305f
C3468 VDD.t156 VSS 0.59305f
C3469 VDD.t60 VSS 0.59305f
C3470 VDD.t158 VSS 0.59305f
C3471 VDD.t161 VSS 0.59305f
C3472 VDD.t163 VSS 0.74131f
C3473 VDD.n243 VSS 2.96523f
C3474 VDD.n244 VSS 0.1112f
C3475 VDD.n245 VSS 0.11625f
C3476 VDD.n246 VSS 0.32083f
C3477 VDD.n247 VSS 0.11851f
C3478 VDD.n248 VSS 0.11851f
C3479 VDD.n249 VSS 0.11625f
C3480 VDD.n250 VSS 0.1112f
C3481 VDD.n251 VSS 2.96523f
C3482 VDD.t78 VSS 2.81697f
C3483 VDD.t79 VSS 0.59305f
C3484 VDD.t14 VSS 0.59305f
C3485 VDD.t73 VSS 0.59305f
C3486 VDD.n252 VSS 1.77914f
C3487 VDD.t92 VSS 0.59305f
C3488 VDD.t94 VSS 0.59305f
C3489 VDD.t96 VSS 1.48261f
C3490 VDD.n253 VSS 2.86937f
C3491 VDD.n254 VSS 0.31283f
C3492 VDD.n255 VSS 0.31283f
C3493 VDD.n256 VSS 0.49718f
C3494 VDD.t16 VSS 2.96523f
C3495 VDD.n257 VSS 3.8548f
C3496 VDD.t203 VSS 1.33435f
C3497 VDD.t499 VSS 0.59305f
C3498 VDD.t501 VSS 0.59305f
C3499 VDD.t301 VSS 1.03783f
C3500 VDD.t82 VSS 1.03783f
C3501 VDD.t88 VSS 0.59305f
C3502 VDD.t85 VSS 0.59305f
C3503 VDD.t58 VSS 0.44478f
C3504 VDD.n258 VSS 0.29652f
C3505 VDD.n259 VSS 0.1112f
C3506 VDD.n260 VSS 0.11625f
C3507 VDD.n261 VSS 0.11851f
C3508 VDD.n262 VSS 0.11851f
C3509 VDD.n263 VSS 0.11851f
C3510 VDD.n264 VSS 0.11625f
C3511 VDD.n265 VSS 0.1112f
C3512 VDD.n266 VSS 4.29958f
C3513 VDD.n267 VSS 7.41307f
C3514 VDD.t353 VSS 0.59305f
C3515 VDD.t351 VSS 0.59305f
C3516 VDD.t357 VSS 1.03783f
C3517 VDD.t299 VSS 1.03783f
C3518 VDD.t309 VSS 0.59305f
C3519 VDD.t461 VSS 0.59305f
C3520 VDD.t513 VSS 1.33435f
C3521 VDD.n268 VSS 3.8548f
C3522 VDD.t12 VSS 2.96523f
C3523 VDD.n269 VSS 0.49718f
C3524 VDD.t10 VSS 0.74131f
C3525 VDD.n270 VSS 4.29958f
C3526 VDD.n271 VSS 0.1112f
C3527 VDD.n272 VSS 0.11625f
C3528 VDD.n273 VSS 0.11851f
C3529 VDD.n274 VSS 0.11851f
C3530 VDD.n275 VSS 0.11851f
C3531 VDD.n276 VSS 0.11625f
C3532 VDD.n277 VSS 0.1112f
C3533 VDD.n278 VSS 0.29652f
C3534 VDD.t305 VSS 0.44478f
C3535 VDD.t345 VSS 0.59305f
C3536 VDD.t343 VSS 0.59305f
C3537 VDD.t347 VSS 1.48261f
C3538 VDD.t71 VSS 0.59305f
C3539 VDD.t1 VSS 0.59305f
C3540 VDD.t0 VSS 0.59305f
C3541 VDD.n279 VSS 1.77914f
C3542 VDD.n280 VSS 2.86937f
C3543 VDD.n281 VSS 0.31283f
C3544 VDD.n282 VSS 0.30813f
C3545 VDD.t473 VSS 0.59305f
C3546 VDD.t475 VSS 0.59305f
C3547 VDD.t455 VSS 0.59305f
C3548 VDD.t307 VSS 0.59305f
C3549 VDD.t479 VSS 0.59305f
C3550 VDD.t481 VSS 0.59305f
C3551 VDD.t483 VSS 1.48261f
C3552 VDD.n283 VSS 2.57284f
C3553 VDD.t564 VSS 1.48261f
C3554 VDD.t566 VSS 0.59305f
C3555 VDD.t572 VSS 0.59305f
C3556 VDD.t574 VSS 0.59305f
C3557 VDD.t570 VSS 0.59305f
C3558 VDD.t568 VSS 0.59305f
C3559 VDD.t576 VSS 0.59305f
C3560 VDD.t578 VSS 0.74131f
C3561 VDD.n284 VSS 2.96523f
C3562 VDD.n285 VSS 0.1112f
C3563 VDD.n286 VSS 0.11625f
C3564 VDD.n287 VSS 0.11851f
C3565 VDD.n288 VSS 0.11851f
C3566 VDD.n289 VSS 0.11851f
C3567 VDD.n290 VSS 0.11625f
C3568 VDD.n291 VSS 0.1112f
C3569 VDD.n292 VSS 2.96523f
C3570 VDD.t2 VSS 2.81697f
C3571 VDD.t148 VSS 0.59305f
C3572 VDD.t19 VSS 0.59305f
C3573 VDD.t465 VSS 0.59305f
C3574 VDD.n293 VSS 1.77914f
C3575 VDD.n294 VSS 4.25907f
C3576 VDD.n295 VSS 5.66794f
C3577 VDD.n296 VSS 0.09536f
C3578 VDD.n297 VSS 0.1383f
C3579 VDD.n298 VSS 0.21775f
C3580 VDD.n299 VSS 0.09443f
C3581 VDD.n300 VSS 0.11851f
C3582 VDD.n301 VSS 0.11625f
C3583 VDD.n302 VSS 5.66794f
C3584 VDD.n303 VSS 0.1112f
C3585 VDD.n304 VSS 3.96216f
C3586 VDD.t438 VSS 1.48261f
C3587 VDD.n305 VSS 0.31283f
C3588 VDD.n306 VSS 7.41307f
C3589 VDD.n307 VSS 0.1112f
C3590 VDD.n308 VSS 0.11851f
C3591 VDD.n309 VSS 0.11851f
C3592 VDD.n310 VSS 0.11851f
C3593 VDD.n311 VSS 0.11625f
C3594 VDD.n312 VSS 0.1112f
C3595 VDD.t277 VSS 2.22392f
C3596 VDD.n313 VSS 0.31283f
C3597 VDD.t29 VSS 0.44478f
C3598 VDD.t245 VSS 1.48261f
C3599 VDD.n314 VSS 0.22239f
C3600 VDD.t557 VSS 0.14826f
C3601 VDD.t239 VSS 0.29652f
C3602 VDD.t559 VSS 0.51891f
C3603 VDD.t62 VSS 0.59305f
C3604 VDD.t64 VSS 0.51891f
C3605 VDD.t235 VSS 0.29652f
C3606 VDD.t66 VSS 0.29652f
C3607 VDD.t233 VSS 0.29652f
C3608 VDD.t142 VSS 0.29652f
C3609 VDD.t231 VSS 0.29652f
C3610 VDD.t144 VSS 0.29652f
C3611 VDD.t229 VSS 0.29652f
C3612 VDD.t146 VSS 0.29652f
C3613 VDD.t227 VSS 0.51891f
C3614 VDD.t225 VSS 0.59305f
C3615 VDD.t213 VSS 0.59305f
C3616 VDD.t223 VSS 0.44478f
C3617 VDD.t292 VSS 0.44478f
C3618 VDD.t247 VSS 0.59305f
C3619 VDD.t275 VSS 0.59305f
C3620 VDD.t271 VSS 0.44478f
C3621 VDD.t400 VSS 0.44478f
C3622 VDD.t399 VSS 0.59305f
C3623 VDD.t412 VSS 0.59305f
C3624 VDD.t411 VSS 0.59305f
C3625 VDD.t298 VSS 0.59305f
C3626 VDD.t297 VSS 0.59305f
C3627 VDD.t293 VSS 0.59305f
C3628 VDD.n315 VSS 0.1112f
C3629 VDD.n316 VSS 0.1112f
C3630 VDD.n317 VSS 0.11625f
C3631 VDD.n318 VSS 0.11851f
C3632 VDD.n319 VSS 0.11851f
C3633 VDD.n320 VSS 0.11851f
C3634 VDD.n321 VSS 0.11851f
C3635 VDD.n322 VSS 0.11851f
C3636 VDD.n323 VSS 0.11625f
C3637 VDD.n324 VSS 0.1112f
C3638 VDD.t54 VSS 2.37218f
C3639 VDD.t266 VSS 1.48261f
C3640 VDD.t265 VSS 0.59305f
C3641 VDD.t264 VSS 0.59305f
C3642 VDD.t26 VSS 0.44478f
C3643 VDD.n325 VSS 0.29652f
C3644 VDD.t25 VSS 0.44478f
C3645 VDD.t263 VSS 0.59305f
C3646 VDD.t262 VSS 0.59305f
C3647 VDD.t261 VSS 1.48261f
C3648 VDD.t56 VSS 2.37218f
C3649 VDD.t249 VSS 1.48261f
C3650 VDD.t273 VSS 2.22392f
C3651 VDD.n326 VSS 0.1112f
C3652 VDD.n327 VSS 0.11851f
C3653 VDD.n328 VSS 0.11851f
C3654 VDD.n329 VSS 0.11851f
C3655 VDD.n330 VSS 0.11851f
C3656 VDD.n331 VSS 0.11625f
C3657 VDD.n332 VSS 0.1112f
C3658 VDD.n333 VSS 5.18915f
C3659 VDD.n334 VSS 3.75893f
C3660 VDD.n335 VSS 0.31283f
C3661 VDD.n336 VSS 0.50199f
C3662 VDD.t173 VSS 2.22392f
C3663 VDD.n337 VSS 0.1112f
C3664 VDD.n338 VSS 0.11851f
C3665 VDD.n339 VSS 0.32083f
C3666 VDD.t175 VSS 0.59305f
C3667 VDD.t179 VSS 0.59305f
C3668 VDD.t181 VSS 0.59305f
C3669 VDD.t183 VSS 0.59305f
C3670 VDD.t185 VSS 0.59305f
C3671 VDD.t187 VSS 0.59305f
C3672 VDD.t189 VSS 1.48261f
C3673 VDD.n340 VSS 3.9767f
C3674 VDD.n341 VSS 5.67493f
C3675 VDD.n342 VSS 0.09948f
C3676 VDD.n343 VSS 0.11625f
C3677 VDD.n344 VSS 0.11625f
C3678 VDD.n345 VSS 0.1112f
C3679 VDD.n346 VSS 2.14979f
C3680 VDD.t442 VSS 0.51891f
C3681 VDD.t440 VSS 3.48415f
C3682 VDD.n347 VSS 7.09482f
C3683 VDD.n348 VSS 7.41307f
C3684 VDD.n349 VSS 0.1112f
C3685 VDD.n350 VSS 0.11625f
C3686 VDD.n351 VSS 0.11625f
C3687 VDD.n352 VSS 0.11625f
C3688 VDD.n353 VSS 0.1112f
C3689 VDD.n354 VSS 0.22239f
C3690 VDD.t422 VSS 0.14826f
C3691 VDD.t237 VSS 0.29652f
C3692 VDD.t420 VSS 0.51891f
C3693 VDD.t403 VSS 0.59305f
C3694 VDD.t401 VSS 0.51891f
C3695 VDD.t205 VSS 0.29652f
C3696 VDD.t415 VSS 0.29652f
C3697 VDD.t207 VSS 0.29652f
C3698 VDD.t413 VSS 0.29652f
C3699 VDD.t209 VSS 0.29652f
C3700 VDD.t200 VSS 0.29652f
C3701 VDD.t211 VSS 0.29652f
C3702 VDD.t198 VSS 0.29652f
C3703 VDD.t219 VSS 0.51891f
C3704 VDD.t221 VSS 0.59305f
C3705 VDD.t217 VSS 0.59305f
C3706 VDD.t215 VSS 0.44478f
C3707 VDD.t167 VSS 0.44478f
C3708 VDD.t166 VSS 0.59305f
C3709 VDD.t498 VSS 0.59305f
C3710 VDD.t497 VSS 0.59305f
C3711 VDD.t496 VSS 0.59305f
C3712 VDD.t135 VSS 0.59305f
C3713 VDD.t134 VSS 0.59305f
C3714 VDD.t133 VSS 0.44478f
C3715 VDD.t243 VSS 0.44478f
C3716 VDD.t251 VSS 0.59305f
C3717 VDD.t253 VSS 0.59305f
C3718 VDD.t21 VSS 0.44478f
C3719 VDD.n355 VSS 0.49718f
C3720 VDD.t23 VSS 0.44478f
C3721 VDD.t257 VSS 0.59305f
C3722 VDD.t259 VSS 0.59305f
C3723 VDD.n356 VSS 0.1112f
C3724 VDD.n357 VSS 0.11625f
C3725 VDD.n358 VSS 0.11625f
C3726 VDD.n359 VSS 0.11625f
C3727 VDD.n360 VSS 0.1112f
C3728 VDD.t241 VSS 0.59305f
C3729 VDD.t267 VSS 0.59305f
C3730 VDD.t27 VSS 0.44478f
C3731 VDD.n361 VSS 0.49718f
C3732 VDD.n362 VSS 0.31283f
C3733 VDD.n363 VSS 0.31283f
C3734 VDD.n364 VSS 3.75893f
C3735 VDD.n365 VSS 5.18915f
C3736 VDD.n366 VSS 0.1112f
C3737 VDD.n367 VSS 0.11625f
C3738 VDD.n368 VSS 0.11625f
C3739 VDD.n369 VSS 0.11625f
C3740 VDD.n370 VSS 0.1112f
C3741 VDD.n371 VSS 7.09482f
C3742 VDD.t177 VSS 3.48415f
C3743 VDD.t171 VSS 0.51891f
C3744 VDD.n372 VSS 2.14979f
C3745 VDD.t424 VSS 2.22392f
C3746 VDD.t428 VSS 0.59305f
C3747 VDD.t426 VSS 0.59305f
C3748 VDD.t436 VSS 0.59305f
C3749 VDD.t434 VSS 0.59305f
C3750 VDD.t432 VSS 0.59305f
C3751 VDD.t430 VSS 0.59305f
C3752 VDD.n373 VSS 0.1112f
C3753 VDD.n374 VSS 0.11625f
C3754 VDD.n375 VSS 0.10183f
C3755 VDD.n376 VSS 0.11699f
C3756 VDD.t278 VSS 0.15543f
C3757 VDD.t240 VSS 0.15546f
C3758 VDD.n377 VSS 0.17169f
C3759 VDD.n378 VSS 0.19228f
C3760 VDD.n379 VSS 0.06693f
C3761 VDD.t236 VSS 0.15455f
C3762 VDD.t234 VSS 0.15079f
C3763 VDD.n380 VSS 0.06703f
C3764 VDD.t232 VSS 0.15079f
C3765 VDD.t230 VSS 0.15079f
C3766 VDD.n381 VSS 0.06651f
C3767 VDD.n382 VSS 0.02995f
C3768 VDD.n383 VSS 0.0444f
C3769 VDD.t216 VSS 0.15455f
C3770 VDD.t218 VSS 0.15079f
C3771 VDD.n384 VSS 0.06703f
C3772 VDD.t222 VSS 0.15079f
C3773 VDD.t220 VSS 0.15079f
C3774 VDD.n385 VSS 0.06651f
C3775 VDD.n386 VSS 0.03371f
C3776 VDD.t212 VSS 0.15079f
C3777 VDD.t210 VSS 0.15079f
C3778 VDD.n387 VSS 0.06651f
C3779 VDD.n388 VSS 0.01533f
C3780 VDD.t199 VSS 0.21999f
C3781 VDD.t201 VSS 0.21609f
C3782 VDD.n389 VSS 0.06703f
C3783 VDD.t414 VSS 0.21609f
C3784 VDD.t416 VSS 0.21609f
C3785 VDD.n390 VSS 0.06651f
C3786 VDD.n391 VSS 0.03089f
C3787 VDD.t238 VSS 0.15543f
C3788 VDD.t274 VSS 0.15546f
C3789 VDD.n392 VSS 0.17169f
C3790 VDD.n393 VSS 0.17726f
C3791 VDD.t174 VSS 0.10503f
C3792 VDD.t176 VSS 0.1033f
C3793 VDD.n394 VSS 0.06703f
C3794 VDD.t180 VSS 0.1033f
C3795 VDD.t182 VSS 0.1033f
C3796 VDD.n395 VSS 0.06651f
C3797 VDD.n396 VSS 0.03371f
C3798 VDD.t184 VSS 0.1033f
C3799 VDD.t186 VSS 0.1033f
C3800 VDD.n397 VSS 0.06651f
C3801 VDD.n398 VSS 0.16674f
C3802 VDD.t188 VSS 0.1033f
C3803 VDD.t190 VSS 0.10503f
C3804 VDD.n399 VSS 0.0694f
C3805 VDD.n400 VSS 0.19721f
C3806 VDD.t441 VSS 0.1312f
C3807 VDD.t443 VSS 0.1312f
C3808 VDD.n401 VSS 0.19605f
C3809 VDD.n402 VSS 0.71648f
C3810 VDD.n403 VSS 0.33113f
C3811 VDD.t421 VSS 0.21609f
C3812 VDD.t423 VSS 0.21609f
C3813 VDD.n404 VSS 0.06651f
C3814 VDD.n405 VSS 0.19622f
C3815 VDD.t402 VSS 0.21609f
C3816 VDD.t404 VSS 0.21609f
C3817 VDD.n406 VSS 0.06651f
C3818 VDD.n407 VSS 0.01439f
C3819 VDD.n408 VSS 0.07368f
C3820 VDD.n409 VSS 0.21306f
C3821 VDD.t208 VSS 0.15079f
C3822 VDD.t206 VSS 0.15086f
C3823 VDD.n410 VSS 0.06651f
C3824 VDD.n411 VSS 0.01875f
C3825 VDD.n412 VSS 0.05002f
C3826 VDD.n413 VSS 0.09134f
C3827 VDD.n414 VSS 0.15641f
C3828 VDD.t24 VSS 0.17664f
C3829 VDD.t22 VSS 0.17667f
C3830 VDD.n415 VSS 0.11016f
C3831 VDD.t250 VSS 0.11494f
C3832 VDD.t260 VSS 0.11494f
C3833 VDD.n416 VSS 0.06651f
C3834 VDD.t252 VSS 0.11494f
C3835 VDD.t244 VSS 0.11771f
C3836 VDD.n417 VSS 0.06651f
C3837 VDD.n418 VSS 0.1153f
C3838 VDD.t255 VSS 0.11494f
C3839 VDD.t254 VSS 0.11494f
C3840 VDD.n419 VSS 0.06651f
C3841 VDD.n420 VSS 0.01908f
C3842 VDD.t258 VSS 0.11494f
C3843 VDD.t256 VSS 0.11494f
C3844 VDD.n421 VSS 0.06651f
C3845 VDD.n422 VSS 0.01908f
C3846 VDD.n423 VSS 0.01514f
C3847 VDD.n424 VSS 0.16559f
C3848 VDD.t57 VSS 0.10137f
C3849 VDD.n425 VSS 0.12776f
C3850 VDD.n426 VSS 0.13642f
C3851 VDD.n427 VSS 0.10637f
C3852 VDD.t30 VSS 0.17664f
C3853 VDD.t28 VSS 0.17667f
C3854 VDD.n428 VSS 0.11016f
C3855 VDD.t272 VSS 0.11771f
C3856 VDD.t276 VSS 0.11494f
C3857 VDD.n429 VSS 0.06703f
C3858 VDD.t248 VSS 0.11494f
C3859 VDD.t270 VSS 0.11494f
C3860 VDD.n430 VSS 0.06651f
C3861 VDD.n431 VSS 0.03371f
C3862 VDD.t269 VSS 0.11494f
C3863 VDD.t268 VSS 0.11494f
C3864 VDD.n432 VSS 0.06651f
C3865 VDD.n433 VSS 0.01908f
C3866 VDD.t242 VSS 0.11494f
C3867 VDD.t246 VSS 0.11494f
C3868 VDD.n434 VSS 0.06651f
C3869 VDD.t55 VSS 0.10137f
C3870 VDD.n435 VSS 0.15302f
C3871 VDD.n436 VSS 0.03649f
C3872 VDD.n437 VSS 0.24234f
C3873 VDD.n438 VSS 0.08437f
C3874 VDD.n439 VSS 0.11263f
C3875 VDD.t214 VSS 0.15079f
C3876 VDD.t224 VSS 0.15455f
C3877 VDD.n440 VSS 0.06651f
C3878 VDD.n441 VSS 0.0927f
C3879 VDD.t228 VSS 0.15079f
C3880 VDD.t226 VSS 0.15079f
C3881 VDD.n442 VSS 0.06651f
C3882 VDD.n443 VSS 0.01533f
C3883 VDD.n445 VSS 0.21335f
C3884 VDD.t145 VSS 0.20986f
C3885 VDD.t147 VSS 0.21364f
C3886 VDD.n446 VSS 0.06651f
C3887 VDD.n447 VSS 0.08651f
C3888 VDD.t67 VSS 0.20986f
C3889 VDD.t143 VSS 0.20986f
C3890 VDD.n448 VSS 0.06651f
C3891 VDD.n449 VSS 0.01908f
C3892 VDD.t63 VSS 0.20986f
C3893 VDD.t65 VSS 0.20986f
C3894 VDD.n450 VSS 0.06651f
C3895 VDD.n451 VSS 0.01908f
C3896 VDD.t558 VSS 0.20986f
C3897 VDD.t560 VSS 0.20986f
C3898 VDD.n452 VSS 0.06651f
C3899 VDD.n453 VSS 0.19622f
C3900 VDD.n454 VSS 0.33864f
C3901 VDD.t172 VSS 0.13292f
C3902 VDD.t178 VSS 0.13292f
C3903 VDD.n455 VSS 0.19605f
C3904 VDD.n456 VSS 0.38261f
C3905 VDD.n457 VSS 0.18991f
C3906 VDD.t439 VSS 0.10177f
C3907 VDD.t431 VSS 0.1001f
C3908 VDD.n458 VSS 0.06703f
C3909 VDD.t433 VSS 0.1001f
C3910 VDD.t435 VSS 0.1001f
C3911 VDD.n459 VSS 0.06651f
C3912 VDD.n460 VSS 0.03371f
C3913 VDD.t437 VSS 0.1001f
C3914 VDD.t427 VSS 0.1001f
C3915 VDD.n461 VSS 0.06651f
C3916 VDD.t429 VSS 0.1001f
C3917 VDD.t425 VSS 0.10177f
C3918 VDD.n462 VSS 0.06651f
C3919 VDD.n463 VSS 0.16279f
C3920 VDD.n464 VSS 0.16674f
C3921 VDD.n465 VSS 0.24402f
C3922 VDD.n466 VSS 5.24571f
C3923 VDD.n467 VSS 26.3265f
C3924 VDD.n468 VSS 0.0696f
C3925 VDD.t304 VSS 0.17478f
C3926 VDD.t306 VSS 0.17478f
C3927 VDD.n469 VSS 0.10479f
C3928 VDD.t310 VSS 0.13917f
C3929 VDD.t300 VSS 0.14159f
C3930 VDD.n470 VSS 0.06703f
C3931 VDD.t514 VSS 0.14159f
C3932 VDD.t462 VSS 0.13917f
C3933 VDD.n471 VSS 0.06651f
C3934 VDD.n472 VSS 0.03346f
C3935 VDD.n473 VSS 0.1717f
C3936 VDD.t359 VSS 0.08227f
C3937 VDD.t349 VSS 0.08227f
C3938 VDD.n474 VSS 0.06703f
C3939 VDD.t360 VSS 0.08227f
C3940 VDD.t346 VSS 0.08227f
C3941 VDD.n475 VSS 0.06651f
C3942 VDD.n476 VSS 0.03371f
C3943 VDD.t362 VSS 0.08227f
C3944 VDD.t361 VSS 0.08227f
C3945 VDD.n477 VSS 0.06651f
C3946 VDD.n478 VSS 0.01908f
C3947 VDD.t364 VSS 0.0836f
C3948 VDD.t363 VSS 0.08227f
C3949 VDD.n479 VSS 0.06651f
C3950 VDD.n480 VSS 0.01908f
C3951 VDD.n481 VSS 0.05886f
C3952 VDD.n482 VSS 0.17177f
C3953 VDD.n483 VSS 0.10291f
C3954 VDD.t17 VSS 0.17517f
C3955 VDD.t562 VSS 0.17521f
C3956 VDD.n484 VSS 0.12129f
C3957 VDD.t302 VSS 0.14464f
C3958 VDD.t502 VSS 0.14216f
C3959 VDD.n485 VSS 0.06703f
C3960 VDD.t500 VSS 0.14216f
C3961 VDD.t204 VSS 0.14464f
C3962 VDD.n486 VSS 0.06651f
C3963 VDD.n487 VSS 0.06856f
C3964 VDD.n488 VSS 0.14429f
C3965 VDD.t469 VSS 0.17369f
C3966 VDD.t59 VSS 0.17369f
C3967 VDD.n489 VSS 0.10479f
C3968 VDD.t458 VSS 0.15098f
C3969 VDD.t464 VSS 0.15363f
C3970 VDD.n490 VSS 0.06703f
C3971 VDD.t504 VSS 0.15363f
C3972 VDD.t460 VSS 0.15098f
C3973 VDD.n491 VSS 0.06651f
C3974 VDD.n492 VSS 0.11193f
C3975 VDD.n493 VSS 0.31493f
C3976 VDD.t155 VSS 0.08492f
C3977 VDD.t153 VSS 0.0863f
C3978 VDD.n494 VSS 0.06703f
C3979 VDD.t157 VSS 0.08492f
C3980 VDD.t151 VSS 0.08492f
C3981 VDD.n495 VSS 0.06651f
C3982 VDD.n496 VSS 0.03371f
C3983 VDD.t159 VSS 0.08492f
C3984 VDD.t160 VSS 0.08492f
C3985 VDD.n497 VSS 0.06651f
C3986 VDD.n498 VSS 0.01908f
C3987 VDD.t164 VSS 0.0863f
C3988 VDD.t162 VSS 0.08492f
C3989 VDD.n499 VSS 0.06651f
C3990 VDD.n500 VSS 0.19289f
C3991 VDD.t61 VSS 0.17367f
C3992 VDD.t165 VSS 0.1737f
C3993 VDD.n501 VSS 0.08207f
C3994 VDD.n502 VSS 0.23807f
C3995 VDD.n503 VSS 0.1292f
C3996 VDD.n504 VSS 0.21343f
C3997 VDD.t47 VSS 0.08111f
C3998 VDD.t33 VSS 0.07983f
C3999 VDD.n505 VSS 0.06651f
C4000 VDD.n506 VSS 0.16472f
C4001 VDD.t35 VSS 0.07983f
C4002 VDD.t37 VSS 0.08111f
C4003 VDD.n507 VSS 0.06703f
C4004 VDD.t41 VSS 0.07983f
C4005 VDD.t39 VSS 0.07983f
C4006 VDD.n508 VSS 0.06651f
C4007 VDD.n509 VSS 0.03371f
C4008 VDD.t45 VSS 0.07983f
C4009 VDD.t43 VSS 0.07983f
C4010 VDD.n510 VSS 0.06651f
C4011 VDD.n511 VSS 0.01533f
C4012 VDD.n512 VSS 0.16085f
C4013 VDD.n513 VSS 0.20216f
C4014 VDD.t294 VSS 0.17519f
C4015 VDD.t15 VSS 0.17519f
C4016 VDD.n514 VSS 0.22264f
C4017 VDD.n515 VSS 0.28193f
C4018 VDD.n516 VSS 0.17077f
C4019 VDD.t98 VSS 0.08525f
C4020 VDD.t83 VSS 0.08525f
C4021 VDD.n517 VSS 0.06703f
C4022 VDD.t101 VSS 0.08525f
C4023 VDD.t100 VSS 0.08525f
C4024 VDD.n518 VSS 0.06651f
C4025 VDD.n519 VSS 0.03371f
C4026 VDD.t99 VSS 0.08525f
C4027 VDD.t102 VSS 0.08525f
C4028 VDD.n520 VSS 0.06651f
C4029 VDD.n521 VSS 0.01908f
C4030 VDD.t104 VSS 0.08663f
C4031 VDD.t103 VSS 0.08525f
C4032 VDD.n522 VSS 0.06651f
C4033 VDD.n523 VSS 0.01908f
C4034 VDD.n524 VSS 0.15563f
C4035 VDD.n525 VSS 0.17177f
C4036 VDD.n526 VSS 0.13306f
C4037 VDD.t97 VSS 0.08663f
C4038 VDD.t95 VSS 0.08525f
C4039 VDD.n527 VSS 0.06651f
C4040 VDD.n528 VSS 0.02972f
C4041 VDD.t93 VSS 0.08525f
C4042 VDD.t91 VSS 0.08525f
C4043 VDD.n529 VSS 0.06651f
C4044 VDD.n530 VSS 0.01908f
C4045 VDD.t84 VSS 0.08525f
C4046 VDD.t86 VSS 0.08525f
C4047 VDD.n531 VSS 0.06651f
C4048 VDD.n532 VSS 0.01908f
C4049 VDD.t89 VSS 0.08525f
C4050 VDD.t87 VSS 0.08525f
C4051 VDD.n533 VSS 0.06651f
C4052 VDD.n534 VSS 0.08933f
C4053 VDD.n535 VSS 0.09559f
C4054 VDD.n536 VSS 0.21371f
C4055 VDD.t11 VSS 0.17041f
C4056 VDD.t13 VSS 0.17044f
C4057 VDD.n537 VSS 0.1798f
C4058 VDD.n538 VSS 0.32216f
C4059 VDD.n539 VSS 0.10854f
C4060 VDD.t344 VSS 0.08227f
C4061 VDD.t348 VSS 0.08227f
C4062 VDD.n540 VSS 0.06703f
C4063 VDD.t355 VSS 0.08227f
C4064 VDD.t350 VSS 0.08227f
C4065 VDD.n541 VSS 0.06651f
C4066 VDD.n542 VSS 0.03371f
C4067 VDD.t354 VSS 0.08227f
C4068 VDD.t356 VSS 0.08227f
C4069 VDD.n543 VSS 0.06651f
C4070 VDD.n544 VSS 0.01908f
C4071 VDD.t358 VSS 0.0836f
C4072 VDD.t352 VSS 0.08227f
C4073 VDD.n545 VSS 0.06651f
C4074 VDD.n546 VSS 0.01908f
C4075 VDD.n547 VSS 0.11704f
C4076 VDD.n548 VSS 0.13262f
C4077 VDD.n549 VSS 0.08413f
C4078 VDD.t80 VSS 0.17042f
C4079 VDD.t81 VSS 0.17042f
C4080 VDD.n550 VSS 0.22264f
C4081 VDD.n551 VSS 0.31949f
C4082 VDD.n552 VSS 0.22094f
C4083 VDD.t579 VSS 0.08719f
C4084 VDD.t577 VSS 0.08579f
C4085 VDD.n553 VSS 0.06651f
C4086 VDD.n554 VSS 0.16472f
C4087 VDD.t567 VSS 0.08579f
C4088 VDD.t565 VSS 0.08719f
C4089 VDD.n555 VSS 0.06703f
C4090 VDD.t575 VSS 0.08579f
C4091 VDD.t573 VSS 0.08579f
C4092 VDD.n556 VSS 0.06651f
C4093 VDD.n557 VSS 0.03371f
C4094 VDD.t569 VSS 0.08579f
C4095 VDD.t571 VSS 0.08579f
C4096 VDD.n558 VSS 0.06651f
C4097 VDD.n559 VSS 0.01533f
C4098 VDD.n560 VSS 0.16085f
C4099 VDD.n561 VSS 0.20592f
C4100 VDD.n562 VSS 0.2067f
C4101 VDD.t474 VSS 0.08639f
C4102 VDD.t472 VSS 0.0878f
C4103 VDD.n563 VSS 0.06703f
C4104 VDD.t477 VSS 0.08639f
C4105 VDD.t476 VSS 0.08639f
C4106 VDD.n564 VSS 0.06651f
C4107 VDD.n565 VSS 0.03371f
C4108 VDD.t480 VSS 0.08639f
C4109 VDD.t478 VSS 0.08639f
C4110 VDD.n566 VSS 0.06651f
C4111 VDD.n567 VSS 0.01908f
C4112 VDD.t484 VSS 0.0878f
C4113 VDD.t482 VSS 0.08639f
C4114 VDD.n568 VSS 0.06651f
C4115 VDD.n569 VSS 0.19289f
C4116 VDD.t308 VSS 0.17477f
C4117 VDD.t456 VSS 0.1748f
C4118 VDD.n570 VSS 0.08207f
C4119 VDD.n571 VSS 0.23807f
C4120 VDD.n572 VSS 0.13296f
C4121 VDD.t20 VSS 0.14563f
C4122 VDD.t466 VSS 0.14818f
C4123 VDD.n573 VSS 0.06703f
C4124 VDD.t3 VSS 0.14818f
C4125 VDD.t149 VSS 0.14563f
C4126 VDD.n574 VSS 0.06651f
C4127 VDD.n575 VSS 0.10201f
C4128 VDD.n576 VSS 0.18996f
C4129 VDD.n577 VSS 18.2228f
C4130 VDD.n578 VSS 21.3908f
C4131 VDD.n579 VSS 9.23303f
C4132 VDD.n580 VSS 21.835f
C4133 VDD.n581 VSS 21.5755f
C4134 E_CAPTURE_CLKB.n0 VSS 0.04638f
C4135 E_CAPTURE_CLKB.n1 VSS 0.04638f
C4136 E_CAPTURE_CLKB.n2 VSS 0.04638f
C4137 E_CAPTURE_CLKB.n3 VSS 0.04638f
C4138 E_CAPTURE_CLKB.n4 VSS 0.13499f
C4139 E_CAPTURE_CLKB.n5 VSS 0.06672f
C4140 E_CAPTURE_CLKB.n6 VSS 0.07152f
C4141 E_CAPTURE_CLKB.n7 VSS 0.07152f
C4142 E_CAPTURE_CLKB.n8 VSS 0.07152f
C4143 E_CAPTURE_CLKB.n9 VSS 0.07152f
C4144 E_CAPTURE_CLKB.n10 VSS 0.07152f
C4145 E_CAPTURE_CLKB.n11 VSS 0.07152f
C4146 E_CAPTURE_CLKB.n12 VSS 0.06759f
C4147 E_CAPTURE_CLKB.n13 VSS 0.29449f
C4148 E_CAPTURE_CLKB.n14 VSS 0.04638f
C4149 E_CAPTURE_CLKB.n15 VSS 0.07152f
C4150 E_CAPTURE_CLKB.n16 VSS 0.13499f
C4151 E_CAPTURE_CLKB.n17 VSS 0.06672f
C4152 E_CAPTURE_CLKB.n18 VSS 0.07152f
C4153 E_CAPTURE_CLKB.n19 VSS 0.07152f
C4154 E_CAPTURE_CLKB.n20 VSS 0.07152f
C4155 E_CAPTURE_CLKB.n21 VSS 0.04638f
C4156 E_CAPTURE_CLKB.n22 VSS 0.04638f
C4157 E_CAPTURE_CLKB.n23 VSS 0.04638f
C4158 E_CAPTURE_CLKB.n24 VSS 0.07152f
C4159 E_CAPTURE_CLKB.n25 VSS 0.07152f
C4160 E_CAPTURE_CLKB.n26 VSS 0.06759f
C4161 E_CAPTURE_CLKB.n27 VSS 0.11864f
C4162 E_CAPTURE_CLKB.n28 VSS 3.28491f
C4163 O_CAPTURE_CLKB.n0 VSS 0.04837f
C4164 O_CAPTURE_CLKB.n1 VSS 0.04837f
C4165 O_CAPTURE_CLKB.n2 VSS 0.04837f
C4166 O_CAPTURE_CLKB.n3 VSS 0.04837f
C4167 O_CAPTURE_CLKB.n4 VSS 0.14078f
C4168 O_CAPTURE_CLKB.n5 VSS 0.06959f
C4169 O_CAPTURE_CLKB.n6 VSS 0.07459f
C4170 O_CAPTURE_CLKB.n7 VSS 0.07459f
C4171 O_CAPTURE_CLKB.n8 VSS 0.07459f
C4172 O_CAPTURE_CLKB.n9 VSS 0.07459f
C4173 O_CAPTURE_CLKB.n10 VSS 0.07459f
C4174 O_CAPTURE_CLKB.n11 VSS 0.07459f
C4175 O_CAPTURE_CLKB.n12 VSS 0.0705f
C4176 O_CAPTURE_CLKB.n13 VSS 0.30713f
C4177 O_CAPTURE_CLKB.n14 VSS 0.04837f
C4178 O_CAPTURE_CLKB.n15 VSS 0.07459f
C4179 O_CAPTURE_CLKB.n16 VSS 0.14078f
C4180 O_CAPTURE_CLKB.n17 VSS 0.06959f
C4181 O_CAPTURE_CLKB.n18 VSS 0.07459f
C4182 O_CAPTURE_CLKB.n19 VSS 0.07459f
C4183 O_CAPTURE_CLKB.n20 VSS 0.07459f
C4184 O_CAPTURE_CLKB.n21 VSS 0.04837f
C4185 O_CAPTURE_CLKB.n22 VSS 0.04837f
C4186 O_CAPTURE_CLKB.n23 VSS 0.04837f
C4187 O_CAPTURE_CLKB.n24 VSS 0.07459f
C4188 O_CAPTURE_CLKB.n25 VSS 0.07459f
C4189 O_CAPTURE_CLKB.n26 VSS 0.0705f
C4190 O_CAPTURE_CLKB.n27 VSS 0.12373f
C4191 O_CAPTURE_CLKB.n28 VSS 7.45643f
C4192 EVEN_Q.t0 VSS 1.30833f
C4193 EVEN_Q.t2 VSS 0.31666f
C4194 EVEN_Q.t1 VSS 0.31666f
C4195 EVEN_Q.n0 VSS 0.95179f
C4196 EVEN_Q.n1 VSS 0.46942f
C4197 EVEN_Q.t5 VSS 1.30323f
C4198 EVEN_Q.n2 VSS 1.50424f
C4199 EVEN_Q.t4 VSS 0.31666f
C4200 EVEN_Q.t3 VSS 0.31666f
C4201 EVEN_Q.n3 VSS 0.94983f
C4202 EVEN_Q.t6 VSS 1.29902f
C4203 EVEN_Q.n4 VSS 0.478f
C4204 EVEN_Q.n5 VSS 2.99553f
C4205 EVEN_QB.t6 VSS 1.23849f
C4206 EVEN_QB.t3 VSS 0.30028f
C4207 EVEN_QB.t2 VSS 0.30028f
C4208 EVEN_QB.n0 VSS 0.90047f
C4209 EVEN_QB.n1 VSS 0.44411f
C4210 EVEN_QB.t0 VSS 1.23367f
C4211 EVEN_QB.n2 VSS 1.42314f
C4212 EVEN_QB.t5 VSS 0.30028f
C4213 EVEN_QB.t4 VSS 0.30028f
C4214 EVEN_QB.n3 VSS 0.89862f
C4215 EVEN_QB.t1 VSS 1.22968f
C4216 EVEN_QB.n4 VSS 0.45223f
C4217 EVEN_QB.n5 VSS 4.71698f
C4218 ODD_QB.t1 VSS 1.12327f
C4219 ODD_QB.t4 VSS 0.28473f
C4220 ODD_QB.t2 VSS 0.28473f
C4221 ODD_QB.n0 VSS 0.8045f
C4222 ODD_QB.n1 VSS 0.39678f
C4223 ODD_QB.t0 VSS 1.11896f
C4224 ODD_QB.n2 VSS 1.21079f
C4225 ODD_QB.t3 VSS 0.28473f
C4226 ODD_QB.t5 VSS 0.28473f
C4227 ODD_QB.n3 VSS 0.80285f
C4228 ODD_QB.t6 VSS 1.1154f
C4229 ODD_QB.n4 VSS 0.41162f
C4230 ODD_QB.n5 VSS 4.3519f
C4231 ODD_Q.t5 VSS 1.33923f
C4232 ODD_Q.t2 VSS 0.326f
C4233 ODD_Q.t1 VSS 0.326f
C4234 ODD_Q.n0 VSS 0.97244f
C4235 ODD_Q.n1 VSS 0.47961f
C4236 ODD_Q.t3 VSS 1.33402f
C4237 ODD_Q.n2 VSS 1.51482f
C4238 ODD_Q.t4 VSS 0.326f
C4239 ODD_Q.t0 VSS 0.326f
C4240 ODD_Q.n3 VSS 0.97044f
C4241 ODD_Q.t6 VSS 1.32972f
C4242 ODD_Q.n4 VSS 0.48981f
C4243 ODD_Q.n5 VSS 2.90226f
C4244 FE_E_N.n0 VSS 0.0414f
C4245 FE_E_N.n1 VSS 0.14301f
C4246 FE_E_N.n2 VSS 0.07069f
C4247 FE_E_N.n3 VSS 0.07577f
C4248 FE_E_N.n4 VSS 0.07577f
C4249 FE_E_N.n5 VSS 0.14301f
C4250 FE_E_N.n6 VSS 0.07069f
C4251 FE_E_N.n7 VSS 0.07577f
C4252 FE_E_N.n8 VSS 0.07577f
C4253 FE_E_N.n9 VSS 0.07577f
C4254 FE_E_N.n10 VSS 0.07577f
C4255 FE_E_N.n11 VSS 0.0414f
C4256 FE_E_N.n12 VSS 0.27018f
C4257 FE_E_N.n13 VSS 0.06968f
C4258 FE_E_N.n14 VSS 0.07577f
C4259 FE_E_N.n15 VSS 0.07577f
C4260 FE_E_N.n16 VSS 0.06968f
C4261 FE_E_N.n17 VSS 0.20867f
C4262 FE_E_N.n18 VSS 7.41709f
C4263 FE_E_N.t13 VSS 0.64082f
C4264 FE_E_N.t6 VSS 0.17376f
C4265 FE_E_N.t7 VSS 0.17376f
C4266 FE_E_N.n19 VSS 0.44782f
C4267 FE_E_N.n20 VSS 0.22087f
C4268 FE_E_N.t3 VSS 0.64082f
C4269 FE_E_N.t4 VSS 0.17376f
C4270 FE_E_N.t5 VSS 0.17376f
C4271 FE_E_N.n21 VSS 0.44782f
C4272 FE_E_N.n22 VSS 0.24615f
C4273 FE_E_N.t8 VSS 0.17376f
C4274 FE_E_N.t9 VSS 0.17376f
C4275 FE_E_N.n23 VSS 0.44782f
C4276 FE_E_N.n24 VSS 0.10321f
C4277 FE_E_N.n25 VSS 0.1003f
C4278 FE_E_N.t0 VSS 0.63975f
C4279 FE_E_N.t1 VSS 0.17376f
C4280 FE_E_N.t2 VSS 0.17376f
C4281 FE_E_N.n26 VSS 0.44452f
C4282 FE_E_N.n27 VSS 0.25052f
C4283 FE_E_N.t10 VSS 0.17376f
C4284 FE_E_N.t11 VSS 0.17376f
C4285 FE_E_N.n28 VSS 0.44452f
C4286 FE_E_N.n29 VSS 0.12548f
C4287 FE_E_N.t12 VSS 0.63438f
C4288 FE_E_N.n30 VSS 0.21396f
C4289 FE_E_N.n31 VSS 0.65891f
C4290 FE_E_N.n32 VSS 7.58218f
C4291 FE_E_P.n0 VSS 0.04106f
C4292 FE_E_P.n1 VSS 0.14185f
C4293 FE_E_P.n2 VSS 0.07011f
C4294 FE_E_P.n3 VSS 0.07515f
C4295 FE_E_P.n4 VSS 0.07515f
C4296 FE_E_P.n5 VSS 0.14185f
C4297 FE_E_P.n6 VSS 0.07011f
C4298 FE_E_P.n7 VSS 0.07515f
C4299 FE_E_P.n8 VSS 0.07515f
C4300 FE_E_P.n9 VSS 0.07515f
C4301 FE_E_P.n10 VSS 0.07515f
C4302 FE_E_P.n11 VSS 0.04106f
C4303 FE_E_P.n12 VSS 0.26798f
C4304 FE_E_P.n13 VSS 0.06912f
C4305 FE_E_P.n14 VSS 0.07515f
C4306 FE_E_P.n15 VSS 0.07515f
C4307 FE_E_P.n16 VSS 0.06912f
C4308 FE_E_P.n17 VSS 0.20698f
C4309 FE_E_P.n18 VSS 7.85988f
C4310 FE_E_P.t2 VSS 0.6396f
C4311 FE_E_P.t3 VSS 0.17626f
C4312 FE_E_P.t4 VSS 0.17626f
C4313 FE_E_P.n19 VSS 0.44418f
C4314 FE_E_P.n20 VSS 0.21907f
C4315 FE_E_P.t9 VSS 0.6396f
C4316 FE_E_P.t7 VSS 0.17626f
C4317 FE_E_P.t8 VSS 0.17626f
C4318 FE_E_P.n21 VSS 0.44418f
C4319 FE_E_P.n22 VSS 0.24415f
C4320 FE_E_P.t5 VSS 0.17626f
C4321 FE_E_P.t6 VSS 0.17626f
C4322 FE_E_P.n23 VSS 0.44418f
C4323 FE_E_P.n24 VSS 0.10237f
C4324 FE_E_P.n25 VSS 0.08888f
C4325 FE_E_P.t1 VSS 0.63854f
C4326 FE_E_P.t13 VSS 0.17626f
C4327 FE_E_P.t0 VSS 0.17626f
C4328 FE_E_P.n26 VSS 0.44091f
C4329 FE_E_P.n27 VSS 0.24849f
C4330 FE_E_P.t11 VSS 0.17626f
C4331 FE_E_P.t12 VSS 0.17626f
C4332 FE_E_P.n28 VSS 0.44091f
C4333 FE_E_P.n29 VSS 0.13073f
C4334 FE_E_P.t10 VSS 0.63281f
C4335 FE_E_P.n30 VSS 0.30377f
C4336 FE_E_P.n31 VSS 0.68508f
C4337 FE_O_P.n0 VSS 0.0377f
C4338 FE_O_P.n1 VSS 0.13025f
C4339 FE_O_P.n2 VSS 0.06438f
C4340 FE_O_P.n3 VSS 0.06901f
C4341 FE_O_P.n4 VSS 0.06901f
C4342 FE_O_P.n5 VSS 0.13025f
C4343 FE_O_P.n6 VSS 0.06438f
C4344 FE_O_P.n7 VSS 0.06901f
C4345 FE_O_P.n8 VSS 0.06901f
C4346 FE_O_P.n9 VSS 0.06901f
C4347 FE_O_P.n10 VSS 0.06901f
C4348 FE_O_P.n11 VSS 0.0377f
C4349 FE_O_P.n12 VSS 0.24607f
C4350 FE_O_P.n13 VSS 0.06346f
C4351 FE_O_P.n14 VSS 0.06901f
C4352 FE_O_P.n15 VSS 0.06901f
C4353 FE_O_P.n16 VSS 0.06346f
C4354 FE_O_P.n17 VSS 0.19005f
C4355 FE_O_P.n18 VSS 6.96851f
C4356 FE_O_P.t6 VSS 0.59157f
C4357 FE_O_P.t7 VSS 0.16604f
C4358 FE_O_P.t8 VSS 0.16604f
C4359 FE_O_P.n19 VSS 0.40786f
C4360 FE_O_P.n20 VSS 0.22419f
C4361 FE_O_P.t1 VSS 0.16604f
C4362 FE_O_P.t2 VSS 0.16604f
C4363 FE_O_P.n21 VSS 0.40786f
C4364 FE_O_P.n22 VSS 0.094f
C4365 FE_O_P.t0 VSS 0.59157f
C4366 FE_O_P.t3 VSS 0.16604f
C4367 FE_O_P.t4 VSS 0.16604f
C4368 FE_O_P.n23 VSS 0.40786f
C4369 FE_O_P.n24 VSS 0.20115f
C4370 FE_O_P.n25 VSS 0.09135f
C4371 FE_O_P.t13 VSS 0.58556f
C4372 FE_O_P.t5 VSS 0.59059f
C4373 FE_O_P.t11 VSS 0.16604f
C4374 FE_O_P.t12 VSS 0.16604f
C4375 FE_O_P.n26 VSS 0.40485f
C4376 FE_O_P.n27 VSS 0.22817f
C4377 FE_O_P.t9 VSS 0.16604f
C4378 FE_O_P.t10 VSS 0.16604f
C4379 FE_O_P.n28 VSS 0.40485f
C4380 FE_O_P.n29 VSS 0.11428f
C4381 FE_O_P.n30 VSS 0.19487f
C4382 FE_O_P.n31 VSS 0.60056f
C4383 FE_O_N.n0 VSS 0.04057f
C4384 FE_O_N.n1 VSS 0.14014f
C4385 FE_O_N.n2 VSS 0.06927f
C4386 FE_O_N.n3 VSS 0.07425f
C4387 FE_O_N.n4 VSS 0.07425f
C4388 FE_O_N.n5 VSS 0.14014f
C4389 FE_O_N.n6 VSS 0.06927f
C4390 FE_O_N.n7 VSS 0.07425f
C4391 FE_O_N.n8 VSS 0.07425f
C4392 FE_O_N.n9 VSS 0.07425f
C4393 FE_O_N.n10 VSS 0.07425f
C4394 FE_O_N.n11 VSS 0.04057f
C4395 FE_O_N.n12 VSS 0.26476f
C4396 FE_O_N.n13 VSS 0.06829f
C4397 FE_O_N.n14 VSS 0.07425f
C4398 FE_O_N.n15 VSS 0.07425f
C4399 FE_O_N.n16 VSS 0.06829f
C4400 FE_O_N.n17 VSS 0.20449f
C4401 FE_O_N.n18 VSS 7.57353f
C4402 FE_O_N.t6 VSS 0.63302f
C4403 FE_O_N.t7 VSS 0.17523f
C4404 FE_O_N.t8 VSS 0.17523f
C4405 FE_O_N.n19 VSS 0.43885f
C4406 FE_O_N.n20 VSS 0.24122f
C4407 FE_O_N.t9 VSS 0.17523f
C4408 FE_O_N.t10 VSS 0.17523f
C4409 FE_O_N.n21 VSS 0.43885f
C4410 FE_O_N.n22 VSS 0.10114f
C4411 FE_O_N.t2 VSS 0.63302f
C4412 FE_O_N.t0 VSS 0.17523f
C4413 FE_O_N.t1 VSS 0.17523f
C4414 FE_O_N.n23 VSS 0.43885f
C4415 FE_O_N.n24 VSS 0.21644f
C4416 FE_O_N.n25 VSS 0.08781f
C4417 FE_O_N.t11 VSS 0.63198f
C4418 FE_O_N.t12 VSS 0.17523f
C4419 FE_O_N.t13 VSS 0.17523f
C4420 FE_O_N.n26 VSS 0.43561f
C4421 FE_O_N.n27 VSS 0.2455f
C4422 FE_O_N.t3 VSS 0.17523f
C4423 FE_O_N.t4 VSS 0.17523f
C4424 FE_O_N.n28 VSS 0.43561f
C4425 FE_O_N.n29 VSS 0.12916f
C4426 FE_O_N.t5 VSS 0.6263f
C4427 FE_O_N.n30 VSS 0.30013f
C4428 FE_O_N.n31 VSS 0.67632f
C4429 FE_O_N.n32 VSS 7.30186f
C4430 E_CAPTURE_CLK.n0 VSS 0.03705f
C4431 E_CAPTURE_CLK.n1 VSS 0.02538f
C4432 E_CAPTURE_CLK.n2 VSS 0.02538f
C4433 E_CAPTURE_CLK.n3 VSS 0.02538f
C4434 E_CAPTURE_CLK.n4 VSS 0.07387f
C4435 E_CAPTURE_CLK.n5 VSS 0.03651f
C4436 E_CAPTURE_CLK.n6 VSS 0.03914f
C4437 E_CAPTURE_CLK.n7 VSS 0.03914f
C4438 E_CAPTURE_CLK.n8 VSS 0.03914f
C4439 E_CAPTURE_CLK.n9 VSS 0.03914f
C4440 E_CAPTURE_CLK.n10 VSS 0.03914f
C4441 E_CAPTURE_CLK.n11 VSS 0.03914f
C4442 E_CAPTURE_CLK.n12 VSS 0.02138f
C4443 E_CAPTURE_CLK.n13 VSS 0.17344f
C4444 E_CAPTURE_CLK.n14 VSS 0.036f
C4445 E_CAPTURE_CLK.n15 VSS 0.02538f
C4446 E_CAPTURE_CLK.n16 VSS 0.03914f
C4447 E_CAPTURE_CLK.n17 VSS 0.03914f
C4448 E_CAPTURE_CLK.n18 VSS 0.03651f
C4449 E_CAPTURE_CLK.n19 VSS 0.07387f
C4450 E_CAPTURE_CLK.n20 VSS 0.02538f
C4451 E_CAPTURE_CLK.n21 VSS 0.03914f
C4452 E_CAPTURE_CLK.n22 VSS 0.03914f
C4453 E_CAPTURE_CLK.n23 VSS 0.03914f
C4454 E_CAPTURE_CLK.n24 VSS 0.03914f
C4455 E_CAPTURE_CLK.n25 VSS 0.02138f
C4456 E_CAPTURE_CLK.n26 VSS 0.07131f
C4457 E_CAPTURE_CLK.n27 VSS 1.62962f
C4458 O_CAPTURE_CLK.n0 VSS 0.0388f
C4459 O_CAPTURE_CLK.n1 VSS 0.02658f
C4460 O_CAPTURE_CLK.n2 VSS 0.02658f
C4461 O_CAPTURE_CLK.n3 VSS 0.02658f
C4462 O_CAPTURE_CLK.n4 VSS 0.07736f
C4463 O_CAPTURE_CLK.n5 VSS 0.03824f
C4464 O_CAPTURE_CLK.n6 VSS 0.04099f
C4465 O_CAPTURE_CLK.n7 VSS 0.04099f
C4466 O_CAPTURE_CLK.n8 VSS 0.04099f
C4467 O_CAPTURE_CLK.n9 VSS 0.04099f
C4468 O_CAPTURE_CLK.n10 VSS 0.04099f
C4469 O_CAPTURE_CLK.n11 VSS 0.04099f
C4470 O_CAPTURE_CLK.n12 VSS 0.02239f
C4471 O_CAPTURE_CLK.n13 VSS 0.23908f
C4472 O_CAPTURE_CLK.n14 VSS 0.0377f
C4473 O_CAPTURE_CLK.n15 VSS 0.02658f
C4474 O_CAPTURE_CLK.n16 VSS 0.04099f
C4475 O_CAPTURE_CLK.n17 VSS 0.04099f
C4476 O_CAPTURE_CLK.n18 VSS 0.03824f
C4477 O_CAPTURE_CLK.n19 VSS 0.07736f
C4478 O_CAPTURE_CLK.n20 VSS 0.02658f
C4479 O_CAPTURE_CLK.n21 VSS 0.04099f
C4480 O_CAPTURE_CLK.n22 VSS 0.04099f
C4481 O_CAPTURE_CLK.n23 VSS 0.04099f
C4482 O_CAPTURE_CLK.n24 VSS 0.04099f
C4483 O_CAPTURE_CLK.n25 VSS 0.02239f
C4484 O_CAPTURE_CLK.n26 VSS 0.12591f
C4485 O_CAPTURE_CLK.n27 VSS 1.83383f
C4486 E_REGEN_CLKB.n0 VSS 0.17455f
C4487 E_REGEN_CLKB.n1 VSS 0.17915f
C4488 E_REGEN_CLKB.n2 VSS 0.12632f
C4489 E_REGEN_CLKB.n3 VSS 0.51947f
C4490 E_REGEN_CLKB.n4 VSS 0.1948f
C4491 E_REGEN_CLKB.n5 VSS 0.12632f
C4492 E_REGEN_CLKB.n6 VSS 0.1948f
C4493 E_REGEN_CLKB.n7 VSS 0.25312f
C4494 E_REGEN_CLKB.n8 VSS 0.27301f
C4495 E_REGEN_CLKB.n9 VSS 0.27301f
C4496 E_REGEN_CLKB.n10 VSS 0.27301f
C4497 E_REGEN_CLKB.n11 VSS 0.53936f
C4498 E_REGEN_CLKB.n12 VSS 0.18173f
C4499 E_REGEN_CLKB.n13 VSS 0.36767f
C4500 E_REGEN_CLKB.n14 VSS 0.1948f
C4501 E_REGEN_CLKB.n15 VSS 0.1948f
C4502 E_REGEN_CLKB.n16 VSS 0.1948f
C4503 E_REGEN_CLKB.n17 VSS 0.1948f
C4504 E_REGEN_CLKB.n18 VSS 0.10643f
C4505 E_REGEN_CLKB.n19 VSS 0.31245f
C4506 E_REGEN_CLKB.n20 VSS 3.46727f
C4507 E_REGEN_CLKB.n21 VSS 0.42113f
C4508 E_REGEN_CLKB.n22 VSS 0.10643f
C4509 E_REGEN_CLKB.n23 VSS 0.1948f
C4510 E_REGEN_CLKB.n24 VSS 0.27301f
C4511 E_REGEN_CLKB.n25 VSS 0.12632f
C4512 E_REGEN_CLKB.n26 VSS 0.12632f
C4513 E_REGEN_CLKB.n27 VSS 0.12632f
C4514 E_REGEN_CLKB.n28 VSS 0.36767f
C4515 E_REGEN_CLKB.n29 VSS 0.27301f
C4516 E_REGEN_CLKB.n30 VSS 0.53936f
C4517 E_REGEN_CLKB.n31 VSS 0.18173f
C4518 E_REGEN_CLKB.n32 VSS 0.1948f
C4519 E_REGEN_CLKB.n33 VSS 0.1948f
C4520 E_REGEN_CLKB.n34 VSS 0.1948f
C4521 E_REGEN_CLKB.n35 VSS 0.1948f
C4522 E_REGEN_CLKB.n36 VSS 0.27301f
C4523 E_REGEN_CLKB.n37 VSS 0.27301f
C4524 E_REGEN_CLKB.n38 VSS 0.25312f
C4525 E_REGEN_CLKB.n39 VSS 0.1948f
C4526 E_REGEN_CLKB.n40 VSS 0.18441f
C4527 E_REGEN_CLKB.n41 VSS 0.18813f
C4528 E_REGEN_CLKB.n42 VSS 2.11028f
C4529 E_REGEN_CLKB.n43 VSS 9.00499f
C4530 O_REGEN_CLKB.n0 VSS 0.17455f
C4531 O_REGEN_CLKB.n1 VSS 0.10643f
C4532 O_REGEN_CLKB.n2 VSS 0.1948f
C4533 O_REGEN_CLKB.n3 VSS 0.27301f
C4534 O_REGEN_CLKB.n4 VSS 0.12632f
C4535 O_REGEN_CLKB.n5 VSS 0.12632f
C4536 O_REGEN_CLKB.n6 VSS 0.36767f
C4537 O_REGEN_CLKB.n7 VSS 0.53936f
C4538 O_REGEN_CLKB.n8 VSS 0.18173f
C4539 O_REGEN_CLKB.n9 VSS 0.1948f
C4540 O_REGEN_CLKB.n10 VSS 0.1948f
C4541 O_REGEN_CLKB.n11 VSS 0.1948f
C4542 O_REGEN_CLKB.n12 VSS 0.27301f
C4543 O_REGEN_CLKB.n13 VSS 0.27301f
C4544 O_REGEN_CLKB.n14 VSS 0.25312f
C4545 O_REGEN_CLKB.n15 VSS 0.1948f
C4546 O_REGEN_CLKB.n16 VSS 0.51947f
C4547 O_REGEN_CLKB.n17 VSS 0.1948f
C4548 O_REGEN_CLKB.n18 VSS 0.17915f
C4549 O_REGEN_CLKB.n19 VSS 0.31245f
C4550 O_REGEN_CLKB.n20 VSS 3.46727f
C4551 O_REGEN_CLKB.n21 VSS 0.42113f
C4552 O_REGEN_CLKB.n22 VSS 0.18441f
C4553 O_REGEN_CLKB.n23 VSS 0.12632f
C4554 O_REGEN_CLKB.n24 VSS 0.12632f
C4555 O_REGEN_CLKB.n25 VSS 0.12632f
C4556 O_REGEN_CLKB.n26 VSS 0.1948f
C4557 O_REGEN_CLKB.n27 VSS 0.25312f
C4558 O_REGEN_CLKB.n28 VSS 0.27301f
C4559 O_REGEN_CLKB.n29 VSS 0.27301f
C4560 O_REGEN_CLKB.n30 VSS 0.27301f
C4561 O_REGEN_CLKB.n31 VSS 0.27301f
C4562 O_REGEN_CLKB.n32 VSS 0.53936f
C4563 O_REGEN_CLKB.n33 VSS 0.18173f
C4564 O_REGEN_CLKB.n34 VSS 0.36767f
C4565 O_REGEN_CLKB.n35 VSS 0.1948f
C4566 O_REGEN_CLKB.n36 VSS 0.1948f
C4567 O_REGEN_CLKB.n37 VSS 0.1948f
C4568 O_REGEN_CLKB.n38 VSS 0.1948f
C4569 O_REGEN_CLKB.n39 VSS 0.1948f
C4570 O_REGEN_CLKB.n40 VSS 0.10643f
C4571 O_REGEN_CLKB.n41 VSS 0.18813f
C4572 O_REGEN_CLKB.n42 VSS 2.11028f
C4573 O_REGEN_CLKB.n43 VSS 9.00499f
C4574 E_REGEN_CLK.n0 VSS 0.81622f
C4575 E_REGEN_CLK.n1 VSS 0.40958f
C4576 E_REGEN_CLK.n2 VSS 0.09349f
C4577 E_REGEN_CLK.n3 VSS 0.14417f
C4578 E_REGEN_CLK.n4 VSS 0.20205f
C4579 E_REGEN_CLK.n5 VSS 0.09349f
C4580 E_REGEN_CLK.n6 VSS 0.09349f
C4581 E_REGEN_CLK.n7 VSS 0.09349f
C4582 E_REGEN_CLK.n8 VSS 0.2721f
C4583 E_REGEN_CLK.n9 VSS 0.20205f
C4584 E_REGEN_CLK.n10 VSS 0.20205f
C4585 E_REGEN_CLK.n11 VSS 0.39916f
C4586 E_REGEN_CLK.n12 VSS 0.1345f
C4587 E_REGEN_CLK.n13 VSS 0.14417f
C4588 E_REGEN_CLK.n14 VSS 0.14417f
C4589 E_REGEN_CLK.n15 VSS 0.14417f
C4590 E_REGEN_CLK.n16 VSS 0.14417f
C4591 E_REGEN_CLK.n17 VSS 0.14417f
C4592 E_REGEN_CLK.n18 VSS 0.20205f
C4593 E_REGEN_CLK.n19 VSS 0.20205f
C4594 E_REGEN_CLK.n20 VSS 0.31304f
C4595 E_REGEN_CLK.n21 VSS 0.13625f
C4596 E_REGEN_CLK.n22 VSS 0.20448f
C4597 E_REGEN_CLK.n23 VSS 0.09349f
C4598 E_REGEN_CLK.n24 VSS 0.09349f
C4599 E_REGEN_CLK.n25 VSS 0.09349f
C4600 E_REGEN_CLK.n26 VSS 0.09349f
C4601 E_REGEN_CLK.n27 VSS 0.14417f
C4602 E_REGEN_CLK.n28 VSS 0.31304f
C4603 E_REGEN_CLK.n29 VSS 0.20205f
C4604 E_REGEN_CLK.n30 VSS 0.20205f
C4605 E_REGEN_CLK.n31 VSS 0.20205f
C4606 E_REGEN_CLK.n32 VSS 0.20205f
C4607 E_REGEN_CLK.n33 VSS 0.20205f
C4608 E_REGEN_CLK.n34 VSS 0.39916f
C4609 E_REGEN_CLK.n35 VSS 0.1345f
C4610 E_REGEN_CLK.n36 VSS 0.2721f
C4611 E_REGEN_CLK.n37 VSS 0.14417f
C4612 E_REGEN_CLK.n38 VSS 0.14417f
C4613 E_REGEN_CLK.n39 VSS 0.14417f
C4614 E_REGEN_CLK.n40 VSS 0.14417f
C4615 E_REGEN_CLK.n41 VSS 0.14417f
C4616 E_REGEN_CLK.n42 VSS 0.13625f
C4617 E_REGEN_CLK.n43 VSS 0.20448f
C4618 E_REGEN_CLK.n44 VSS 0.34583f
C4619 E_REGEN_CLK.n45 VSS 1.08296f
C4620 E_REGEN_CLK.n46 VSS 0.07877f
C4621 E_REGEN_CLK.n47 VSS 0.2721f
C4622 E_REGEN_CLK.n48 VSS 0.1345f
C4623 E_REGEN_CLK.n49 VSS 0.14417f
C4624 E_REGEN_CLK.n50 VSS 0.14417f
C4625 E_REGEN_CLK.n51 VSS 0.14417f
C4626 E_REGEN_CLK.n52 VSS 0.1345f
C4627 E_REGEN_CLK.n53 VSS 0.2721f
C4628 E_REGEN_CLK.n54 VSS 0.14417f
C4629 E_REGEN_CLK.n55 VSS 0.14417f
C4630 E_REGEN_CLK.n56 VSS 0.14417f
C4631 E_REGEN_CLK.n57 VSS 0.07877f
C4632 E_REGEN_CLK.n58 VSS 0.51577f
C4633 E_REGEN_CLK.n59 VSS 1.55282f
C4634 E_REGEN_CLK.n60 VSS 2.56208f
C4635 E_REGEN_CLK.n61 VSS 0.33721f
C4636 E_REGEN_CLK.n62 VSS 0.09349f
C4637 E_REGEN_CLK.n63 VSS 0.14417f
C4638 E_REGEN_CLK.n64 VSS 0.20205f
C4639 E_REGEN_CLK.n65 VSS 0.14417f
C4640 E_REGEN_CLK.n66 VSS 0.09349f
C4641 E_REGEN_CLK.n67 VSS 0.1345f
C4642 E_REGEN_CLK.n68 VSS 0.14417f
C4643 E_REGEN_CLK.n69 VSS 0.39916f
C4644 E_REGEN_CLK.n70 VSS 0.20205f
C4645 E_REGEN_CLK.n71 VSS 0.14417f
C4646 E_REGEN_CLK.n72 VSS 0.2721f
C4647 E_REGEN_CLK.n73 VSS 0.09349f
C4648 E_REGEN_CLK.n74 VSS 0.09349f
C4649 E_REGEN_CLK.n75 VSS 0.14417f
C4650 E_REGEN_CLK.n76 VSS 0.20205f
C4651 E_REGEN_CLK.n77 VSS 0.20205f
C4652 E_REGEN_CLK.n78 VSS 0.20205f
C4653 E_REGEN_CLK.n79 VSS 0.14417f
C4654 E_REGEN_CLK.n80 VSS 0.13625f
C4655 E_REGEN_CLK.n81 VSS 0.16511f
C4656 E_REGEN_CLK.n82 VSS 1.27388f
C4657 E_REGEN_CLK.n83 VSS 1.49796f
C4658 E_REGEN_CLK.n84 VSS 0.57533f
C4659 E_REGEN_CLK.n85 VSS 3.84382f
C4660 O_REGEN_CLK.n0 VSS 0.81622f
C4661 O_REGEN_CLK.n1 VSS 0.40958f
C4662 O_REGEN_CLK.n2 VSS 0.09349f
C4663 O_REGEN_CLK.n3 VSS 0.14417f
C4664 O_REGEN_CLK.n4 VSS 0.20205f
C4665 O_REGEN_CLK.n5 VSS 0.09349f
C4666 O_REGEN_CLK.n6 VSS 0.09349f
C4667 O_REGEN_CLK.n7 VSS 0.09349f
C4668 O_REGEN_CLK.n8 VSS 0.2721f
C4669 O_REGEN_CLK.n9 VSS 0.20205f
C4670 O_REGEN_CLK.n10 VSS 0.20205f
C4671 O_REGEN_CLK.n11 VSS 0.39916f
C4672 O_REGEN_CLK.n12 VSS 0.1345f
C4673 O_REGEN_CLK.n13 VSS 0.14417f
C4674 O_REGEN_CLK.n14 VSS 0.14417f
C4675 O_REGEN_CLK.n15 VSS 0.14417f
C4676 O_REGEN_CLK.n16 VSS 0.14417f
C4677 O_REGEN_CLK.n17 VSS 0.14417f
C4678 O_REGEN_CLK.n18 VSS 0.20205f
C4679 O_REGEN_CLK.n19 VSS 0.20205f
C4680 O_REGEN_CLK.n20 VSS 0.31304f
C4681 O_REGEN_CLK.n21 VSS 0.13625f
C4682 O_REGEN_CLK.n22 VSS 0.20448f
C4683 O_REGEN_CLK.n23 VSS 0.09349f
C4684 O_REGEN_CLK.n24 VSS 0.14417f
C4685 O_REGEN_CLK.n25 VSS 0.20205f
C4686 O_REGEN_CLK.n26 VSS 0.09349f
C4687 O_REGEN_CLK.n27 VSS 0.09349f
C4688 O_REGEN_CLK.n28 VSS 0.09349f
C4689 O_REGEN_CLK.n29 VSS 0.2721f
C4690 O_REGEN_CLK.n30 VSS 0.20205f
C4691 O_REGEN_CLK.n31 VSS 0.20205f
C4692 O_REGEN_CLK.n32 VSS 0.39916f
C4693 O_REGEN_CLK.n33 VSS 0.1345f
C4694 O_REGEN_CLK.n34 VSS 0.14417f
C4695 O_REGEN_CLK.n35 VSS 0.14417f
C4696 O_REGEN_CLK.n36 VSS 0.14417f
C4697 O_REGEN_CLK.n37 VSS 0.14417f
C4698 O_REGEN_CLK.n38 VSS 0.14417f
C4699 O_REGEN_CLK.n39 VSS 0.20205f
C4700 O_REGEN_CLK.n40 VSS 0.20205f
C4701 O_REGEN_CLK.n41 VSS 0.31304f
C4702 O_REGEN_CLK.n42 VSS 0.13625f
C4703 O_REGEN_CLK.n43 VSS 0.20448f
C4704 O_REGEN_CLK.n44 VSS 0.34583f
C4705 O_REGEN_CLK.n45 VSS 1.08296f
C4706 O_REGEN_CLK.n46 VSS 0.07877f
C4707 O_REGEN_CLK.n47 VSS 0.2721f
C4708 O_REGEN_CLK.n48 VSS 0.1345f
C4709 O_REGEN_CLK.n49 VSS 0.14417f
C4710 O_REGEN_CLK.n50 VSS 0.14417f
C4711 O_REGEN_CLK.n51 VSS 0.14417f
C4712 O_REGEN_CLK.n52 VSS 0.1345f
C4713 O_REGEN_CLK.n53 VSS 0.2721f
C4714 O_REGEN_CLK.n54 VSS 0.14417f
C4715 O_REGEN_CLK.n55 VSS 0.14417f
C4716 O_REGEN_CLK.n56 VSS 0.14417f
C4717 O_REGEN_CLK.n57 VSS 0.07877f
C4718 O_REGEN_CLK.n58 VSS 0.51577f
C4719 O_REGEN_CLK.n59 VSS 1.55282f
C4720 O_REGEN_CLK.n60 VSS 2.56208f
C4721 O_REGEN_CLK.n61 VSS 0.33721f
C4722 O_REGEN_CLK.n62 VSS 0.09349f
C4723 O_REGEN_CLK.n63 VSS 0.09349f
C4724 O_REGEN_CLK.n64 VSS 0.09349f
C4725 O_REGEN_CLK.n65 VSS 0.09349f
C4726 O_REGEN_CLK.n66 VSS 0.2721f
C4727 O_REGEN_CLK.n67 VSS 0.20205f
C4728 O_REGEN_CLK.n68 VSS 0.20205f
C4729 O_REGEN_CLK.n69 VSS 0.20205f
C4730 O_REGEN_CLK.n70 VSS 0.20205f
C4731 O_REGEN_CLK.n71 VSS 0.20205f
C4732 O_REGEN_CLK.n72 VSS 0.39916f
C4733 O_REGEN_CLK.n73 VSS 0.1345f
C4734 O_REGEN_CLK.n74 VSS 0.14417f
C4735 O_REGEN_CLK.n75 VSS 0.14417f
C4736 O_REGEN_CLK.n76 VSS 0.14417f
C4737 O_REGEN_CLK.n77 VSS 0.14417f
C4738 O_REGEN_CLK.n78 VSS 0.14417f
C4739 O_REGEN_CLK.n79 VSS 0.14417f
C4740 O_REGEN_CLK.n80 VSS 0.13625f
C4741 O_REGEN_CLK.n81 VSS 0.16511f
C4742 O_REGEN_CLK.n82 VSS 1.27388f
C4743 O_REGEN_CLK.n83 VSS 1.49796f
C4744 O_REGEN_CLK.n84 VSS 0.57533f
C4745 O_REGEN_CLK.n85 VSS 3.84382f
C4746 E_SENSE_CLK.n0 VSS 0.35044f
C4747 E_SENSE_CLK.n1 VSS 0.35044f
C4748 E_SENSE_CLK.n2 VSS 2.18951f
C4749 E_SENSE_CLK.n3 VSS 0.43843f
C4750 E_SENSE_CLK.n4 VSS 2.26622f
C4751 E_SENSE_CLK.n5 VSS 1.65396f
C4752 E_SENSE_CLK.n6 VSS 6.97478f
C4753 O_SENSE_CLK.n0 VSS 0.35044f
C4754 O_SENSE_CLK.n1 VSS 0.35044f
C4755 O_SENSE_CLK.n2 VSS 2.18951f
C4756 O_SENSE_CLK.n3 VSS 0.43843f
C4757 O_SENSE_CLK.n4 VSS 2.26622f
C4758 O_SENSE_CLK.n5 VSS 1.65396f
C4759 O_SENSE_CLK.n6 VSS 6.97478f
C4760 SAMP_E_P.t4 VSS 0.14604f
C4761 SAMP_E_P.n0 VSS 0.40502f
C4762 SAMP_E_P.n1 VSS 0.97957f
C4763 SAMP_E_P.n2 VSS 0.09614f
C4764 SAMP_E_P.t2 VSS 0.34171f
C4765 SAMP_E_P.n3 VSS 0.09849f
C4766 SAMP_E_P.t3 VSS 0.34171f
C4767 SAMP_E_P.n4 VSS 0.09849f
C4768 SAMP_E_P.n5 VSS 0.08374f
C4769 SAMP_E_P.n6 VSS 0.30761f
C4770 SAMP_E_P.t1 VSS 0.34451f
C4771 SAMP_E_P.t0 VSS 0.34441f
C4772 SAMP_E_P.n7 VSS 0.22787f
C4773 SAMP_E_P.n8 VSS 0.72311f
C4774 SAMP_E_P.n9 VSS 1.89647f
C4775 SAMP_E_P.n10 VSS 1.88655f
C4776 SAMP_E_N.t2 VSS 0.10963f
C4777 SAMP_E_N.t0 VSS 0.26998f
C4778 SAMP_E_N.t1 VSS 0.27005f
C4779 SAMP_E_N.n0 VSS 0.17105f
C4780 SAMP_E_N.n1 VSS 0.21765f
C4781 SAMP_E_N.n2 VSS 0.72649f
C4782 SAMP_E_N.n3 VSS 0.0526f
C4783 SAMP_E_N.t4 VSS 0.28004f
C4784 SAMP_E_N.t3 VSS 0.28004f
C4785 SAMP_E_N.n4 VSS 0.07393f
C4786 SAMP_E_N.n5 VSS 0.07393f
C4787 SAMP_E_N.n6 VSS 0.06286f
C4788 SAMP_E_N.n7 VSS 0.23091f
C4789 SAMP_E_N.n8 VSS 0.54281f
C4790 SAMP_E_N.n9 VSS 1.42361f
C4791 SAMP_E_N.n10 VSS 1.12332f
C4792 E_SENSE_BOOST.n0 VSS 0.04667f
C4793 E_SENSE_BOOST.n1 VSS 0.0554f
C4794 E_SENSE_BOOST.n2 VSS 0.16124f
C4795 E_SENSE_BOOST.n3 VSS 0.0797f
C4796 E_SENSE_BOOST.n4 VSS 0.08543f
C4797 E_SENSE_BOOST.n5 VSS 0.08543f
C4798 E_SENSE_BOOST.n6 VSS 0.08543f
C4799 E_SENSE_BOOST.n7 VSS 0.08543f
C4800 E_SENSE_BOOST.n8 VSS 0.08087f
C4801 E_SENSE_BOOST.n9 VSS 1.44212f
C4802 SAMP_O_P.t2 VSS 0.10995f
C4803 SAMP_O_P.n0 VSS 0.28447f
C4804 SAMP_O_P.n1 VSS 0.79165f
C4805 SAMP_O_P.n2 VSS 0.05276f
C4806 SAMP_O_P.t3 VSS 0.28066f
C4807 SAMP_O_P.n3 VSS 0.07415f
C4808 SAMP_O_P.t4 VSS 0.28066f
C4809 SAMP_O_P.n4 VSS 0.07415f
C4810 SAMP_O_P.n5 VSS 0.06304f
C4811 SAMP_O_P.n6 VSS 0.2316f
C4812 SAMP_O_P.t1 VSS 0.26967f
C4813 SAMP_O_P.t0 VSS 0.26959f
C4814 SAMP_O_P.n7 VSS 0.17156f
C4815 SAMP_O_P.n8 VSS 0.54441f
C4816 SAMP_O_P.n9 VSS 1.42782f
C4817 SAMP_O_P.n10 VSS 1.12665f
C4818 SAMP_O_N.t2 VSS 0.14591f
C4819 SAMP_O_N.t1 VSS 0.3452f
C4820 SAMP_O_N.t0 VSS 0.3453f
C4821 SAMP_O_N.n0 VSS 0.22767f
C4822 SAMP_O_N.n1 VSS 0.30724f
C4823 SAMP_O_N.n2 VSS 0.90469f
C4824 SAMP_O_N.n3 VSS 0.09606f
C4825 SAMP_O_N.t4 VSS 0.34157f
C4826 SAMP_O_N.t3 VSS 0.34157f
C4827 SAMP_O_N.n4 VSS 0.0984f
C4828 SAMP_O_N.n5 VSS 0.0984f
C4829 SAMP_O_N.n6 VSS 0.08366f
C4830 SAMP_O_N.n7 VSS 0.30735f
C4831 SAMP_O_N.n8 VSS 0.72247f
C4832 SAMP_O_N.n9 VSS 1.89481f
C4833 SAMP_O_N.n10 VSS 1.8849f
C4834 O_SENSE_BOOST.n0 VSS 0.08087f
C4835 O_SENSE_BOOST.n1 VSS 0.0554f
C4836 O_SENSE_BOOST.n2 VSS 0.08543f
C4837 O_SENSE_BOOST.n3 VSS 0.0797f
C4838 O_SENSE_BOOST.n4 VSS 0.16124f
C4839 O_SENSE_BOOST.n5 VSS 0.08543f
C4840 O_SENSE_BOOST.n6 VSS 0.08543f
C4841 O_SENSE_BOOST.n7 VSS 0.08543f
C4842 O_SENSE_BOOST.n8 VSS 0.04667f
C4843 O_SENSE_BOOST.n9 VSS 1.44212f
C4844 RX_RESTN.n0 VSS 0.13623f
C4845 RX_RESTN.n1 VSS 0.47066f
C4846 RX_RESTN.n2 VSS 2.92409f
C4847 RX_RESTN.t0 VSS 0.11488f
C4848 RX_RESTN.t1 VSS 0.46315f
C4849 RX_RESTN.t2 VSS 0.46315f
C4850 RX_RESTN.n3 VSS 0.20876f
C4851 RX_RESTN.n4 VSS 1.09392f
C4852 RX_RESTP.n0 VSS 0.46983f
C4853 RX_RESTP.n1 VSS 0.21633f
C4854 RX_RESTP.n2 VSS 3.88442f
C4855 RX_RESTP.t0 VSS 0.11779f
C4856 RX_RESTP.t1 VSS 0.46518f
C4857 RX_RESTP.t2 VSS 0.46518f
C4858 RX_RESTP.n3 VSS 0.21405f
C4859 RX_RESTP.n4 VSS 1.08937f
C4860 PI_CLK_P.n0 VSS 0.07536f
C4861 PI_CLK_P.n1 VSS 0.14482f
C4862 PI_CLK_P.n2 VSS 2.1641f
C4863 PI_CLK_P.t1 VSS 0.21957f
C4864 PI_CLK_P.t2 VSS 0.21957f
C4865 PI_CLK_P.n3 VSS 0.09132f
C4866 PI_CLK_P.t0 VSS 0.04346f
C4867 PI_CLK_P.n4 VSS 8.64166f
C4868 PI_CLK_N.n0 VSS 0.0617f
C4869 PI_CLK_N.n1 VSS 0.1254f
C4870 PI_CLK_N.n2 VSS 1.65367f
C4871 PI_CLK_N.t0 VSS 0.21221f
C4872 PI_CLK_N.t1 VSS 0.21221f
C4873 PI_CLK_N.n3 VSS 0.08342f
C4874 PI_CLK_N.t2 VSS 0.03911f
C4875 PI_CLK_N.n4 VSS 7.48498f
C4876 SAMP_BIAS.n0 VSS 0.02864f
C4877 SAMP_BIAS.n1 VSS 0.03072f
C4878 SAMP_BIAS.n2 VSS 0.03072f
C4879 SAMP_BIAS.n3 VSS 0.02864f
C4880 SAMP_BIAS.n4 VSS 0.25264f
C4881 SAMP_BIAS.n5 VSS 0.02864f
C4882 SAMP_BIAS.n6 VSS 0.03072f
C4883 SAMP_BIAS.n7 VSS 0.03072f
C4884 SAMP_BIAS.n8 VSS 0.02864f
C4885 SAMP_BIAS.n9 VSS 0.08713f
C4886 SAMP_BIAS.n10 VSS 2.16477f
C4887 CLK_REST_BIAS.n0 VSS 0.04295f
C4888 CLK_REST_BIAS.n1 VSS 0.04563f
C4889 CLK_REST_BIAS.n2 VSS 0.04563f
C4890 CLK_REST_BIAS.n3 VSS 0.04295f
C4891 CLK_REST_BIAS.n4 VSS 0.32382f
C4892 CLK_REST_BIAS.n5 VSS 0.04295f
C4893 CLK_REST_BIAS.n6 VSS 0.04563f
C4894 CLK_REST_BIAS.n7 VSS 0.04563f
C4895 CLK_REST_BIAS.n8 VSS 0.04295f
C4896 CLK_REST_BIAS.n9 VSS 0.11419f
C4897 CLK_REST_BIAS.n10 VSS 1.24853f
C4898 REST_BIAS.n0 VSS 0.02944f
C4899 REST_BIAS.n1 VSS 0.03128f
C4900 REST_BIAS.n2 VSS 0.03128f
C4901 REST_BIAS.n3 VSS 0.02944f
C4902 REST_BIAS.n4 VSS 0.22195f
C4903 REST_BIAS.n5 VSS 0.02944f
C4904 REST_BIAS.n6 VSS 0.03128f
C4905 REST_BIAS.n7 VSS 0.03128f
C4906 REST_BIAS.n8 VSS 0.02944f
C4907 REST_BIAS.n9 VSS 0.07827f
C4908 REST_BIAS.n10 VSS 1.38426f
C4909 PI_RAW_P.n0 VSS 0.06074f
C4910 PI_RAW_P.t0 VSS 0.03119f
C4911 PI_RAW_P.t1 VSS 0.08077f
C4912 PI_RAW_P.t2 VSS 0.08079f
C4913 PI_RAW_P.n1 VSS 0.09053f
C4914 PI_RAW_P.n2 VSS 1.79293f
C4915 PI_RAW_P.n3 VSS 1.69797f
C4916 PI_RAW_N.n0 VSS 0.05408f
C4917 PI_RAW_N.t0 VSS 0.02761f
C4918 PI_RAW_N.t1 VSS 0.07926f
C4919 PI_RAW_N.t2 VSS 0.07924f
C4920 PI_RAW_N.n1 VSS 0.08013f
C4921 PI_RAW_N.n2 VSS 1.04721f
C4922 PHASE_A_P.n0 VSS 0.14267f
C4923 PHASE_B_P.n0 VSS 0.23291f
C4924 PHASE_B_N.n0 VSS 0.26623f
C4925 PHASE_A_N.n0 VSS 0.14243f
C4926 PI_BUF_BIAS.n0 VSS 0.02478f
C4927 PI_BUF_BIAS.n1 VSS 0.02659f
C4928 PI_BUF_BIAS.n2 VSS 0.02659f
C4929 PI_BUF_BIAS.n3 VSS 0.02478f
C4930 PI_BUF_BIAS.n4 VSS 0.08576f
C4931 PI_CTRL_A.n0 VSS 0.01893f
C4932 PI_CTRL_A.n1 VSS 0.02131f
C4933 PI_CTRL_A.n2 VSS 0.02131f
C4934 PI_CTRL_A.n3 VSS 0.01893f
C4935 PI_CTRL_A.n4 VSS 0.12577f
C4936 PI_CTRL_B.n0 VSS 0.0114f
C4937 PI_CTRL_B.n1 VSS 0.01283f
C4938 PI_CTRL_B.n2 VSS 0.01283f
C4939 PI_CTRL_B.n3 VSS 0.0114f
C4940 PI_CTRL_B.n4 VSS 0.13262f
C4941 RX_RAWP.n0 VSS 0.50786f
C4942 RX_RAWP.t2 VSS 0.07485f
C4943 RX_RAWP.t1 VSS 0.23743f
C4944 RX_RAWP.t3 VSS 0.18226f
C4945 RX_RAWP.t0 VSS 0.18231f
C4946 RX_RAWP.n1 VSS 0.32417f
C4947 RX_RAWP.n2 VSS 1.0692f
C4948 RX_RAWP.n3 VSS 0.45242f
C4949 RX_RAWN.n0 VSS 0.47865f
C4950 RX_RAWN.t0 VSS 0.07027f
C4951 RX_RAWN.t1 VSS 0.23918f
C4952 RX_RAWN.t2 VSS 0.17321f
C4953 RX_RAWN.t3 VSS 0.17316f
C4954 RX_RAWN.n1 VSS 0.30433f
C4955 RX_RAWN.n2 VSS 1.00377f
C4956 RX_RAWN.n3 VSS 0.42473f
C4957 RX_BW_EN_N.n0 VSS 2.37285f
C4958 RX_BW_EN_N.n1 VSS 1.30569f
C4959 RX_BW_EN_N.n2 VSS 1.47388f
C4960 VTHP.n0 VSS 0.61322f
C4961 VTHN.n0 VSS 0.63951f
C4962 RX_BIAS.n0 VSS 0.02779f
C4963 RX_BIAS.n1 VSS 0.02951f
C4964 RX_BIAS.n2 VSS 0.02951f
C4965 RX_BIAS.n3 VSS 0.02951f
C4966 RX_BIAS.n4 VSS 0.02779f
C4967 RX_BIAS.n5 VSS 0.11903f
C4968 RX_BIAS.n6 VSS 0.01107f
C4969 RX_BIAS.n7 VSS 0.01376f
C4970 RX_BIAS.n8 VSS 0.01376f
C4971 RX_BIAS.n9 VSS 0.01107f
C4972 RX_BIAS.n10 VSS 0.27482f
C4973 RX_BIAS.n11 VSS 0.02779f
C4974 RX_BIAS.n12 VSS 0.02951f
C4975 RX_BIAS.n13 VSS 0.02951f
C4976 RX_BIAS.n14 VSS 0.02951f
C4977 RX_BIAS.n15 VSS 0.02779f
C4978 RX_BIAS.n16 VSS 0.10781f
C4979 RX_BIAS.n17 VSS 0.72566f
C4980 RX_BIAS.n18 VSS 0.71306f
C4981 RXP.t7 VSS 0.17644f
C4982 RXP.n0 VSS 0.53777f
C4983 RXP.n1 VSS 2.23071f
C4984 RXP.t4 VSS 0.03572f
C4985 RXP.t5 VSS 0.03572f
C4986 RXP.t3 VSS 0.03572f
C4987 RXP.t6 VSS 0.03572f
C4988 RXP.t1 VSS 0.03572f
C4989 RXP.t0 VSS 0.03515f
C4990 RXP.t2 VSS 0.05222f
C4991 RXP.n2 VSS 0.77274f
C4992 RXP.n3 VSS 0.46341f
C4993 RXP.n4 VSS 0.46341f
C4994 RXP.n5 VSS 0.46341f
C4995 RXP.n6 VSS 0.46341f
C4996 RXP.n7 VSS 0.42489f
C4997 RXN.t6 VSS 0.07002f
C4998 RXN.n0 VSS 0.21341f
C4999 RXN.n1 VSS 0.88522f
C5000 RXN.t1 VSS 0.01418f
C5001 RXN.t2 VSS 0.01418f
C5002 RXN.t7 VSS 0.01418f
C5003 RXN.t3 VSS 0.01418f
C5004 RXN.t0 VSS 0.01418f
C5005 RXN.t4 VSS 0.01395f
C5006 RXN.t5 VSS 0.02072f
C5007 RXN.n2 VSS 0.30665f
C5008 RXN.n3 VSS 0.1839f
C5009 RXN.n4 VSS 0.1839f
C5010 RXN.n5 VSS 0.1839f
C5011 RXN.n6 VSS 0.1839f
C5012 RXN.n7 VSS 0.16861f
C5013 TERM_EN6_N.n0 VSS 0.40332f
C5014 TERM_EN6_N.n1 VSS 1.74029f
C5015 TERM_EN6_N.n2 VSS 0.71327f
C5016 TERM_EN5_N.n0 VSS 0.41634f
C5017 TERM_EN5_N.n1 VSS 1.79643f
C5018 TERM_EN5_N.n2 VSS 0.73628f
C5019 TERM_EN4_N.n0 VSS 0.41634f
C5020 TERM_EN4_N.n1 VSS 1.79643f
C5021 TERM_EN4_N.n2 VSS 0.73628f
C5022 TERM_EN3_N.n0 VSS 0.41634f
C5023 TERM_EN3_N.n1 VSS 1.79643f
C5024 TERM_EN3_N.n2 VSS 0.73628f
C5025 TERM_EN2_N.n0 VSS 0.41634f
C5026 TERM_EN2_N.n1 VSS 1.79643f
C5027 TERM_EN2_N.n2 VSS 0.73628f
C5028 TERM_EN1_N.n0 VSS 0.41296f
C5029 TERM_EN1_N.n1 VSS 1.78188f
C5030 TERM_EN1_N.n2 VSS 0.73031f
C5031 TERM_EN0_N.n0 VSS 0.38663f
C5032 TERM_EN0_N.n1 VSS 1.66825f
C5033 TERM_EN0_N.n2 VSS 0.68374f
.ends
