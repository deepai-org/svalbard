* PEX produced using /foss/tools/sak/sak-pex.sh with m=3 and s=1 (extresist threshold=0 mOhm, minres=1 mOhm, mindelay=0 ps)
* NGSPICE file created from lane_rx_pi_capture_pex.ext - technology: gf180mcuD

.subckt lane_rx_pi_capture_pex RXP RXN TERM_EN0_N TERM_EN1_N TERM_EN2_N TERM_EN3_N
+ TERM_EN4_N TERM_EN5_N TERM_EN6_N VTHP VTHN RX_BIAS RX_BW_EN_N REST_BIAS SAMP_BIAS
+ E_SENSE_CLK E_REGEN_CLK E_REGEN_CLKB E_CAPTURE_CLK E_CAPTURE_CLKB E_SENSE_BOOST
+ O_SENSE_CLK O_REGEN_CLK O_REGEN_CLKB O_CAPTURE_CLK O_CAPTURE_CLKB O_SENSE_BOOST
+ VDD VSS PHASE_A_P PHASE_A_N PHASE_B_P PHASE_B_N PI_CTRL_A PI_CTRL_B PI_BUF_BIAS
+ CLK_REST_BIAS PI_RAW_P PI_RAW_N PI_CLK_P PI_CLK_N RX_RAWP RX_RAWN RX_RESTP RX_RESTN
+ SAMP_E_P SAMP_E_N SAMP_O_P SAMP_O_N FE_E_P FE_E_N FE_O_P FE_O_N EVEN_Q EVEN_QB ODD_Q
+ ODD_QB
X0 VSS.t236 XRX.XFRONT.XFE_O.H.t19 FE_O_P.t2 VSS.t235 nfet_03v3 ad=2.08p pd=8.52u as=2.08p ps=8.52u w=8u l=0.28u
X1 XRX.XFRONT.XFE_E.NIP.t1 SAMP_E_N.t13 XRX.XFRONT.XFE_E.NTAIL.t2 VSS.t2 nfet_03v3 ad=2.08p pd=8.52u as=2.08p ps=8.52u w=8u l=0.28u
X2 XRX.XCAP.O_PRST_TAIL.t2 O_CAPTURE_CLKB.t14 VDD.t116 VDD.t115 pfet_03v3 ad=2.08p pd=8.52u as=2.08p ps=8.52u w=8u l=0.28u
X3 XRX.XCAP.ODD_DB_BUF.t1 FE_O_P.t9 VSS.t139 VSS.t138 nfet_03v3 ad=2.08p pd=8.52u as=2.08p ps=8.52u w=8u l=0.28u
X4 VSS.t532 RX_BIAS.t4 a_2148_n500.t3 VSS.t517 nfet_03v3 ad=2.6p pd=10.52u as=4.4p ps=20.88u w=10u l=0.28u
X5 a_n10800_n17972.t0 TERM_EN3_N.t2 VSS.t535 VSS.t41 nfet_03v3 ad=0.44p pd=2.88u as=0.44p ps=2.88u w=1u l=0.28u
X6 XRX.XFRONT.XFE_E.NTAIL.t36 E_SENSE_BOOST.t8 VSS.t334 VSS.t333 nfet_03v3 ad=2.6p pd=10.52u as=2.6p ps=10.52u w=10u l=0.28u
X7 PI_CLK_N.t2 a_66600_32348.t3 a_65148_38800.t5 VSS.t386 nfet_03v3 ad=4.4p pd=20.88u as=2.6p ps=10.52u w=10u l=0.28u
X8 a_12148_44200.t4 SAMP_O_N.t6 SAMP_O_P.t2 VSS.t502 nfet_03v3 ad=1.56p pd=6.52u as=2.64p ps=12.88u w=6u l=0.28u
X9 VSS.t69 E_CAPTURE_CLK.t3 XRX.XCAP.E_RST_TAIL.t5 VSS.t68 nfet_03v3 ad=2.08p pd=8.52u as=2.08p ps=8.52u w=8u l=0.28u
X10 XRX.XFRONT.XFE_E.XN.t14 E_SENSE_CLK.t26 XRX.XFRONT.XFE_E.XP.t14 VDD.t202 pfet_03v3 ad=2.08p pd=8.52u as=3.52p ps=16.88u w=8u l=0.28u
X11 XRX.XFRONT.XFE_O.NIP.t6 XRX.XFRONT.XFE_O.XN.t37 XRX.XFRONT.XFE_O.XP.t6 VSS.t165 nfet_03v3 ad=2.08p pd=8.52u as=2.08p ps=8.52u w=8u l=0.28u
X12 XRX.XFRONT.XFE_O.NTAIL.t26 O_SENSE_BOOST.t18 VSS.t539 VSS.t538 nfet_03v3 ad=2.6p pd=10.52u as=2.6p ps=10.52u w=10u l=0.28u
X13 a_80148_31500.t5 PI_BUF_BIAS.t2 VSS.t611 VSS.t610 nfet_03v3 ad=2.6p pd=10.52u as=2.6p ps=10.52u w=10u l=0.28u
X14 VDD.t408 E_CAPTURE_CLKB.t13 XRX.XCAP.E_PRST_TAIL.t4 VDD.t407 pfet_03v3 ad=2.08p pd=8.52u as=2.08p ps=8.52u w=8u l=0.28u
X15 XRX.XCAP.O_RST_TAIL.t5 O_CAPTURE_CLK.t6 VSS.t215 VSS.t214 nfet_03v3 ad=2.08p pd=8.52u as=2.08p ps=8.52u w=8u l=0.28u
X16 VSS.t255 XRX.XCAP.O_QBI.t15 XRX.XCAP.O_QBUF.t3 VSS.t254 nfet_03v3 ad=1.04p pd=4.52u as=1.76p ps=8.88u w=4u l=0.28u
X17 XRX.XFRONT.XFE_O.H.t4 XRX.XFRONT.XFE_O.HB.t25 VDD.t394 VDD.t393 pfet_03v3 ad=3.52p pd=16.88u as=2.08p ps=8.52u w=8u l=0.28u
X18 XRX.XFRONT.XFE_O.H.t8 XRX.XFRONT.XFE_O.DP.t10 VSS.t179 VSS.t178 nfet_03v3 ad=2.08p pd=8.52u as=2.08p ps=8.52u w=8u l=0.28u
X19 FE_E_P.t5 XRX.XFRONT.XFE_E.HB.t26 VDD.t396 VDD.t395 pfet_03v3 ad=3.52p pd=16.88u as=2.08p ps=8.52u w=8u l=0.28u
X20 VDD.t330 O_SENSE_CLK.t6 XRX.XFRONT.XFE_O.XN.t30 VDD.t329 pfet_03v3 ad=2.08p pd=8.52u as=2.08p ps=8.52u w=8u l=0.28u
X21 XRX.XFRONT.XFE_E.HB.t2 XRX.XFRONT.XFE_E.H.t27 VDD.t380 VDD.t379 pfet_03v3 ad=2.08p pd=8.52u as=2.08p ps=8.52u w=8u l=0.28u
X22 a_n7157_n21700.t4 a_n10800_n21572.t3 a_n6400_n21652.t3 VSS.t355 nfet_03v3 ad=4.4p pd=20.88u as=2.6p ps=10.52u w=10u l=0.28u
X23 a_66600_32348.t2 PI_RAW_N.t3 a_65148_29400.t6 VSS.t386 nfet_03v3 ad=4.4p pd=20.88u as=2.6p ps=10.52u w=10u l=0.28u
X24 XRX.XFRONT.XFE_E.NTAIL.t22 E_SENSE_BOOST.t22 VSS.t308 VSS.t307 nfet_03v3 ad=2.6p pd=10.52u as=2.6p ps=10.52u w=10u l=0.28u
X25 VDD.t85 FE_E_P.t16 XRX.XCAP.EVEN_DB_BUF.t6 VDD.t84 pfet_03v3 ad=2.08p pd=8.52u as=2.08p ps=8.52u w=8u l=0.28u
X26 VSS.t205 O_CAPTURE_CLK.t13 XRX.XCAP.O_SET_TAIL.t5 VSS.t77 nfet_03v3 ad=2.08p pd=8.52u as=2.08p ps=8.52u w=8u l=0.28u
X27 SAMP_E_P.t4 RX_RESTN.t5 a_948_44200.t5 VSS.t619 nfet_03v3 ad=2.64p pd=12.88u as=1.56p ps=6.52u w=6u l=0.28u
X28 VSS.t416 FE_E_N.t10 XRX.XCAP.EVEN_D_BUF.t0 VSS.t415 nfet_03v3 ad=2.08p pd=8.52u as=3.52p ps=16.88u w=8u l=0.28u
X29 a_2148_n500.t8 a_n6572_3500.t7 RX_RAWP.t3 VSS.t376 nfet_03v3 ad=1.3p pd=5.52u as=2.2p ps=10.88u w=5u l=0.28u
X30 a_65148_29400.t3 CLK_REST_BIAS.t0 VSS.t296 VSS.t292 nfet_03v3 ad=5.28p pd=24.88u as=3.12p ps=12.52u w=12u l=0.28u
X31 XRX.XCAP.E_RST_TAIL.t8 E_CAPTURE_CLK.t0 VSS.t73 VSS.t72 nfet_03v3 ad=3.52p pd=16.88u as=2.08p ps=8.52u w=8u l=0.28u
X32 VDD.t197 E_SENSE_CLK.t30 XRX.XFRONT.XFE_E.NIN.t18 VDD.t196 pfet_03v3 ad=2.08p pd=8.52u as=3.52p ps=16.88u w=8u l=0.28u
X33 XRX.XFRONT.XFE_E.NIP.t18 E_SENSE_CLK.t17 VDD.t211 VDD.t210 pfet_03v3 ad=2.08p pd=8.52u as=2.08p ps=8.52u w=8u l=0.28u
X34 XRX.XFRONT.XFE_E.NIN.t8 SAMP_E_P.t9 XRX.XFRONT.XFE_E.NTAIL.t12 VSS.t83 nfet_03v3 ad=2.08p pd=8.52u as=2.08p ps=8.52u w=8u l=0.28u
X35 VDD.t129 O_CAPTURE_CLKB.t1 XRX.XCAP.O_PSET_TAIL.t10 VDD.t119 pfet_03v3 ad=2.08p pd=8.52u as=2.08p ps=8.52u w=8u l=0.28u
X36 a_n5052_2600.t1 VTHN.t1 a_n3600_5641.t2 VSS.t350 nfet_03v3 ad=0.52p pd=2.52u as=0.88p ps=4.88u w=2u l=0.28u
X37 XRX.XFRONT.XFE_O.DN.t3 XRX.XFRONT.XFE_O.XN.t44 VSS.t458 VSS.t457 nfet_03v3 ad=3.52p pd=16.88u as=2.08p ps=8.52u w=8u l=0.28u
X38 XRX.XFRONT.XFE_E.NIP.t7 SAMP_E_N.t7 XRX.XFRONT.XFE_E.NTAIL.t4 VSS.t8 nfet_03v3 ad=3.52p pd=16.88u as=2.08p ps=8.52u w=8u l=0.28u
X39 RX_RESTN.t2 a_600_22678.t3 a_n852_28800.t7 VSS.t126 nfet_03v3 ad=4.4p pd=20.88u as=2.6p ps=10.52u w=10u l=0.28u
X40 VSS.t524 RX_BIAS.t13 a_n5052_2600.t4 VSS.t523 nfet_03v3 ad=0.52p pd=2.52u as=0.88p ps=4.88u w=2u l=0.28u
X41 XRX.XCAP.ODD_D_BUF.t7 FE_O_N.t15 VDD.t38 VDD.t37 pfet_03v3 ad=2.08p pd=8.52u as=2.08p ps=8.52u w=8u l=0.28u
X42 VSS.t365 XRX.XCAP.E_QI.t15 XRX.XCAP.E_QBBUF.t0 VSS.t364 nfet_03v3 ad=1.04p pd=4.52u as=1.76p ps=8.88u w=4u l=0.28u
X43 VSS.t445 XRX.XFRONT.XFE_E.DN.t7 XRX.XFRONT.XFE_E.HB.t13 VSS.t444 nfet_03v3 ad=2.08p pd=8.52u as=2.08p ps=8.52u w=8u l=0.28u
X44 XRX.XFRONT.XFE_O.NIP.t23 XRX.XFRONT.XFE_O.XN.t43 XRX.XFRONT.XFE_O.XP.t31 VSS.t456 nfet_03v3 ad=2.08p pd=8.52u as=3.52p ps=16.88u w=8u l=0.28u
X45 XRX.XCAP.E_PSET_TAIL.t11 E_CAPTURE_CLKB.t0 VDD.t426 VDD.t405 pfet_03v3 ad=3.52p pd=16.88u as=2.08p ps=8.52u w=8u l=0.28u
X46 XRX.XCAP.O_SET_TAIL.t8 O_CAPTURE_CLK.t10 VSS.t208 VSS.t31 nfet_03v3 ad=2.08p pd=8.52u as=2.08p ps=8.52u w=8u l=0.28u
X47 VDD.t491 XRX.XFRONT.XFE_O.XP.t49 XRX.XFRONT.XFE_O.DP.t5 VDD.t490 pfet_03v3 ad=2.08p pd=8.52u as=3.52p ps=16.88u w=8u l=0.28u
X48 VDD.t422 E_CAPTURE_CLKB.t7 XRX.XCAP.E_PSET_TAIL.t4 VDD.t416 pfet_03v3 ad=2.08p pd=8.52u as=3.52p ps=16.88u w=8u l=0.28u
X49 a_n6400_n18052.t1 a_n10800_n17972.t2 a_n7300_n18100.t1 VSS.t424 nfet_03v3 ad=2.6p pd=10.52u as=4.4p ps=20.88u w=10u l=0.28u
X50 XRX.XCAP.O_PRST_TAIL.t9 XRX.XCAP.ODD_D_BUF.t19 XRX.XCAP.O_QBI.t8 VDD.t57 pfet_03v3 ad=2.08p pd=8.52u as=3.52p ps=16.88u w=8u l=0.28u
X51 a_65148_38800.t3 CLK_REST_BIAS.t4 VSS.t293 VSS.t292 nfet_03v3 ad=5.28p pd=24.88u as=3.12p ps=12.52u w=12u l=0.28u
X52 XRX.XFRONT.XFE_O.NTAIL.t1 O_SENSE_CLK.t3 VSS.t369 VSS.t368 nfet_03v3 ad=2.6p pd=10.52u as=2.6p ps=10.52u w=10u l=0.28u
X53 VDD.t167 XRX.XCAP.O_QBI.t19 XRX.XCAP.O_QBUF.t1 VDD.t166 pfet_03v3 ad=2.08p pd=8.52u as=3.52p ps=16.88u w=8u l=0.28u
X54 a_600_22678.t1 RX_RAWN.t4 a_n852_19400.t4 VSS.t126 nfet_03v3 ad=4.4p pd=20.88u as=2.6p ps=10.52u w=10u l=0.28u
X55 XRX.XFRONT.XFE_E.DN.t0 XRX.XFRONT.XFE_E.XN.t48 VDD.t266 VDD.t265 pfet_03v3 ad=2.08p pd=8.52u as=2.08p ps=8.52u w=8u l=0.28u
X56 XRX.XFRONT.XFE_E.NTAIL.t28 E_SENSE_BOOST.t16 VSS.t314 VSS.t313 nfet_03v3 ad=2.6p pd=10.52u as=2.6p ps=10.52u w=10u l=0.28u
X57 XRX.XCAP.E_PRST_TAIL.t10 XRX.XCAP.EVEN_D_BUF.t17 XRX.XCAP.E_QBI.t10 VDD.t59 pfet_03v3 ad=2.08p pd=8.52u as=2.08p ps=8.52u w=8u l=0.28u
X58 VDD.t318 O_SENSE_CLK.t12 XRX.XFRONT.XFE_O.XN.t24 VDD.t317 pfet_03v3 ad=2.08p pd=8.52u as=2.08p ps=8.52u w=8u l=0.28u
X59 a_n852_19400.t3 REST_BIAS.t0 VSS.t99 VSS.t94 nfet_03v3 ad=5.28p pd=24.88u as=3.12p ps=12.52u w=12u l=0.28u
X60 VDD.t154 XRX.XCAP.O_QI.t17 XRX.XCAP.O_QBI.t4 VDD.t107 pfet_03v3 ad=2.08p pd=8.52u as=3.52p ps=16.88u w=8u l=0.28u
X61 XRX.XFRONT.XFE_E.NTAIL.t5 SAMP_E_N.t10 XRX.XFRONT.XFE_E.NIP.t4 VSS.t5 nfet_03v3 ad=2.08p pd=8.52u as=2.08p ps=8.52u w=8u l=0.28u
X62 XRX.XFRONT.XFE_E.XP.t31 E_SENSE_CLK.t5 VDD.t237 VDD.t236 pfet_03v3 ad=3.52p pd=16.88u as=2.08p ps=8.52u w=8u l=0.28u
X63 a_n6400_n12652.t2 RXN.t3 VSS.t158 ppolyf_u r_width=1u r_length=1u
X64 XRX.XFRONT.XFE_E.HB.t10 XRX.XFRONT.XFE_E.DN.t10 VSS.t402 VSS.t401 nfet_03v3 ad=2.08p pd=8.52u as=2.08p ps=8.52u w=8u l=0.28u
X65 RXP.t7 a_n7157_n23500.t4 VSS.t11 ppolyf_u r_width=1u r_length=2.43u
X66 XRX.XCAP.E_RST_TAIL.t2 E_CAPTURE_CLK.t6 VSS.t65 VSS.t64 nfet_03v3 ad=2.08p pd=8.52u as=2.08p ps=8.52u w=8u l=0.28u
X67 a_n5052_2600.t5 RX_BIAS.t12 VSS.t525 VSS.t523 nfet_03v3 ad=0.52p pd=2.52u as=0.52p ps=2.52u w=2u l=0.28u
X68 XRX.XFRONT.XFE_O.NTAIL.t34 O_SENSE_BOOST.t10 VSS.t559 VSS.t558 nfet_03v3 ad=2.6p pd=10.52u as=2.6p ps=10.52u w=10u l=0.28u
X69 XRX.XCAP.EVEN_D_BUF.t5 FE_E_N.t17 VDD.t366 VDD.t365 pfet_03v3 ad=2.08p pd=8.52u as=2.08p ps=8.52u w=8u l=0.28u
X70 XRX.XFRONT.XFE_O.NTAIL.t9 SAMP_O_P.t14 XRX.XFRONT.XFE_O.NIP.t12 VSS.t405 nfet_03v3 ad=2.08p pd=8.52u as=3.52p ps=16.88u w=8u l=0.28u
X71 XRX.XCAP.E_QBI.t7 XRX.XCAP.E_QI.t16 VDD.t262 VDD.t261 pfet_03v3 ad=3.52p pd=16.88u as=2.08p ps=8.52u w=8u l=0.28u
X72 VSS.t488 XRX.XCAP.O_QBBUF.t6 ODD_Q.t2 VSS.t487 nfet_03v3 ad=2.08p pd=8.52u as=3.52p ps=16.88u w=8u l=0.28u
X73 XRX.XFRONT.XFE_O.NIP.t15 SAMP_O_P.t11 XRX.XFRONT.XFE_O.NTAIL.t12 VSS.t408 nfet_03v3 ad=2.08p pd=8.52u as=2.08p ps=8.52u w=8u l=0.28u
X74 XRX.XCAP.EVEN_DB_BUF.t1 FE_E_P.t9 VSS.t150 VSS.t149 nfet_03v3 ad=2.08p pd=8.52u as=2.08p ps=8.52u w=8u l=0.28u
X75 VDD.t54 PI_CLK_P.t0 VSS.t132 ppolyf_u r_width=2u r_length=7.5u
X76 VDD.t346 XRX.XFRONT.XFE_O.HB.t28 XRX.XFRONT.XFE_O.H.t1 VDD.t345 pfet_03v3 ad=2.08p pd=8.52u as=3.52p ps=16.88u w=8u l=0.28u
X77 EVEN_QB.t1 XRX.XCAP.E_QBUF.t9 VDD.t143 VDD.t142 pfet_03v3 ad=2.08p pd=8.52u as=2.08p ps=8.52u w=8u l=0.28u
X78 a_n852_28800.t3 REST_BIAS.t4 VSS.t95 VSS.t94 nfet_03v3 ad=5.28p pd=24.88u as=3.12p ps=12.52u w=12u l=0.28u
X79 VSS.t312 E_SENSE_BOOST.t19 XRX.XFRONT.XFE_E.NTAIL.t25 VSS.t311 nfet_03v3 ad=2.6p pd=10.52u as=2.6p ps=10.52u w=10u l=0.28u
X80 VDD.t348 XRX.XCAP.O_QBBUF.t10 ODD_Q.t1 VDD.t347 pfet_03v3 ad=2.08p pd=8.52u as=3.52p ps=16.88u w=8u l=0.28u
X81 VDD.t125 O_CAPTURE_CLKB.t5 XRX.XCAP.O_PSET_TAIL.t6 VDD.t113 pfet_03v3 ad=2.08p pd=8.52u as=2.08p ps=8.52u w=8u l=0.28u
X82 XRX.XCAP.EVEN_D_BUF.t3 FE_E_N.t7 VSS.t418 VSS.t417 nfet_03v3 ad=3.52p pd=16.88u as=2.08p ps=8.52u w=8u l=0.28u
X83 VDD.t352 XRX.XFRONT.XFE_E.XN.t51 XRX.XFRONT.XFE_E.H.t15 VDD.t351 pfet_03v3 ad=2.08p pd=8.52u as=2.08p ps=8.52u w=8u l=0.28u
X84 VSS.t291 CLK_REST_BIAS.t3 a_65148_29400.t0 VSS.t287 nfet_03v3 ad=3.12p pd=12.52u as=5.28p ps=24.88u w=12u l=0.28u
X85 XRX.XFRONT.XFE_O.H.t14 XRX.XFRONT.XFE_O.XN.t54 VDD.t376 VDD.t375 pfet_03v3 ad=2.08p pd=8.52u as=2.08p ps=8.52u w=8u l=0.28u
X86 XRX.XFRONT.XFE_O.HB.t16 XRX.XFRONT.XFE_O.XP.t52 VDD.t485 VDD.t484 pfet_03v3 ad=2.08p pd=8.52u as=2.08p ps=8.52u w=8u l=0.28u
X87 XRX.XFRONT.XFE_E.H.t7 XRX.XFRONT.XFE_E.DP.t8 VSS.t474 VSS.t473 nfet_03v3 ad=2.08p pd=8.52u as=2.08p ps=8.52u w=8u l=0.28u
X88 XRX.XFRONT.XFE_O.XP.t11 O_SENSE_CLK.t37 VDD.t288 VDD.t287 pfet_03v3 ad=2.08p pd=8.52u as=2.08p ps=8.52u w=8u l=0.28u
X89 XRX.XFRONT.XFE_E.NIN.t21 E_SENSE_CLK.t27 VDD.t201 VDD.t200 pfet_03v3 ad=3.52p pd=16.88u as=2.08p ps=8.52u w=8u l=0.28u
X90 a_n10800_n23372.t0 TERM_EN0_N.t2 VSS.t349 VSS.t41 nfet_03v3 ad=0.44p pd=2.88u as=0.44p ps=2.88u w=1u l=0.28u
X91 VDD.t479 a_65000_32348.t2 VSS.t132 ppolyf_u r_width=2u r_length=7.5u
X92 VDD.t44 FE_O_N.t12 XRX.XCAP.ODD_D_BUF.t10 VDD.t43 pfet_03v3 ad=2.08p pd=8.52u as=2.08p ps=8.52u w=8u l=0.28u
X93 XRX.XFRONT.XFE_O.XP.t18 O_SENSE_CLK.t21 XRX.XFRONT.XFE_O.XN.t19 VDD.t302 pfet_03v3 ad=2.08p pd=8.52u as=2.08p ps=8.52u w=8u l=0.28u
X94 XRX.XFRONT.XFE_E.NTAIL.t34 E_SENSE_BOOST.t10 VSS.t324 VSS.t323 nfet_03v3 ad=2.6p pd=10.52u as=2.6p ps=10.52u w=10u l=0.28u
X95 XRX.XFRONT.XFE_E.XN.t30 XRX.XFRONT.XFE_E.XP.t32 XRX.XFRONT.XFE_E.NIN.t22 VSS.t622 nfet_03v3 ad=3.52p pd=16.88u as=2.08p ps=8.52u w=8u l=0.28u
X96 XRX.XFRONT.XFE_O.XN.t11 XRX.XFRONT.XFE_O.XP.t34 XRX.XFRONT.XFE_O.NIN.t6 VSS.t272 nfet_03v3 ad=2.08p pd=8.52u as=2.08p ps=8.52u w=8u l=0.28u
X97 VDD.t471 XRX.XFRONT.XFE_O.H.t26 FE_O_P.t6 VDD.t470 pfet_03v3 ad=3.52p pd=16.88u as=2.08p ps=8.52u w=8u l=0.28u
X98 XRX.XFRONT.XFE_O.NTAIL.t7 SAMP_O_P.t8 XRX.XFRONT.XFE_O.NIP.t18 VSS.t411 nfet_03v3 ad=2.08p pd=8.52u as=2.08p ps=8.52u w=8u l=0.28u
X99 XRX.XCAP.O_QBI.t1 XRX.XCAP.ODD_D_BUF.t16 XRX.XCAP.O_PRST_TAIL.t0 VDD.t0 pfet_03v3 ad=3.52p pd=16.88u as=2.08p ps=8.52u w=8u l=0.28u
X100 a_n7300_n14500.t0 TERM_EN5_N.t1 a_n6400_n14452.t1 VDD.t15 pfet_03v3 ad=4.4p pd=20.88u as=2.6p ps=10.52u w=10u l=0.28u
X101 XRX.XFRONT.XFE_O.NIP.t4 XRX.XFRONT.XFE_O.XN.t35 XRX.XFRONT.XFE_O.XP.t4 VSS.t163 nfet_03v3 ad=2.08p pd=8.52u as=2.08p ps=8.52u w=8u l=0.28u
X102 XRX.XFRONT.XFE_O.HB.t9 XRX.XFRONT.XFE_O.DN.t6 VSS.t470 VSS.t469 nfet_03v3 ad=3.52p pd=16.88u as=2.08p ps=8.52u w=8u l=0.28u
X103 XRX.XFRONT.XFE_O.NTAIL.t28 O_SENSE_BOOST.t16 VSS.t551 VSS.t550 nfet_03v3 ad=2.6p pd=10.52u as=2.6p ps=10.52u w=10u l=0.28u
X104 XRX.XCAP.O_RST_TAIL.t7 O_CAPTURE_CLK.t4 VSS.t216 VSS.t103 nfet_03v3 ad=2.08p pd=8.52u as=2.08p ps=8.52u w=8u l=0.28u
X105 VSS.t288 CLK_REST_BIAS.t7 a_65148_38800.t0 VSS.t287 nfet_03v3 ad=3.12p pd=12.52u as=5.28p ps=24.88u w=12u l=0.28u
X106 a_10548_44200.t1 PI_CLK_N.t3 a_11748_41600.t6 VSS.t177 nfet_03v3 ad=3.52p pd=16.88u as=2.08p ps=8.52u w=8u l=0.28u
X107 VDD.t461 XRX.XCAP.E_QBI.t19 XRX.XCAP.E_QBUF.t1 VDD.t460 pfet_03v3 ad=2.08p pd=8.52u as=3.52p ps=16.88u w=8u l=0.28u
X108 VSS.t587 XRX.XFRONT.XFE_E.DP.t11 XRX.XFRONT.XFE_E.H.t4 VSS.t586 nfet_03v3 ad=2.08p pd=8.52u as=2.08p ps=8.52u w=8u l=0.28u
X109 VDD.t292 O_SENSE_CLK.t34 XRX.XFRONT.XFE_O.XP.t14 VDD.t291 pfet_03v3 ad=2.08p pd=8.52u as=2.08p ps=8.52u w=8u l=0.28u
X110 FE_E_P.t2 XRX.XFRONT.XFE_E.HB.t28 VDD.t260 VDD.t259 pfet_03v3 ad=2.08p pd=8.52u as=3.52p ps=16.88u w=8u l=0.28u
X111 VSS.t320 E_SENSE_BOOST.t13 XRX.XFRONT.XFE_E.NTAIL.t31 VSS.t319 nfet_03v3 ad=2.6p pd=10.52u as=2.6p ps=10.52u w=10u l=0.28u
X112 a_n5052_n1000.t5 RX_BIAS.t8 VSS.t529 VSS.t520 nfet_03v3 ad=2.6p pd=10.52u as=2.6p ps=10.52u w=10u l=0.28u
X113 a_n10800_n12572.t1 TERM_EN6_N.t3 VDD.t28 VDD.t27 pfet_03v3 ad=0.88p pd=4.88u as=0.88p ps=4.88u w=2u l=0.28u
X114 VDD.t465 XRX.XFRONT.XFE_O.H.t23 XRX.XFRONT.XFE_O.HB.t11 VDD.t464 pfet_03v3 ad=2.08p pd=8.52u as=2.08p ps=8.52u w=8u l=0.28u
X115 XRX.XCAP.O_QI.t1 XRX.XCAP.O_QBI.t12 VSS.t34 VSS.t33 nfet_03v3 ad=3.52p pd=16.88u as=2.08p ps=8.52u w=8u l=0.28u
X116 XRX.XFRONT.XFE_O.XP.t26 XRX.XFRONT.XFE_O.XN.t32 XRX.XFRONT.XFE_O.NIP.t20 VSS.t441 nfet_03v3 ad=3.52p pd=16.88u as=2.08p ps=8.52u w=8u l=0.28u
X117 VSS.t298 E_SENSE_BOOST.t1 XRX.XFRONT.XFE_E.NTAIL.t43 VSS.t297 nfet_03v3 ad=2.6p pd=10.52u as=2.6p ps=10.52u w=10u l=0.28u
X118 XRX.XCAP.O_QBBUF.t1 XRX.XCAP.O_QI.t14 VSS.t625 VSS.t117 nfet_03v3 ad=1.76p pd=8.88u as=1.04p ps=4.52u w=4u l=0.28u
X119 VSS.t557 O_SENSE_BOOST.t13 XRX.XFRONT.XFE_O.NTAIL.t31 VSS.t556 nfet_03v3 ad=2.6p pd=10.52u as=2.6p ps=10.52u w=10u l=0.28u
X120 a_n7300_n18100.t3 TERM_EN3_N.t1 a_n6400_n18052.t3 VDD.t434 pfet_03v3 ad=4.4p pd=20.88u as=2.6p ps=10.52u w=10u l=0.28u
X121 VSS.t221 O_CAPTURE_CLK.t1 XRX.XCAP.O_RST_TAIL.t10 VSS.t220 nfet_03v3 ad=2.08p pd=8.52u as=2.08p ps=8.52u w=8u l=0.28u
X122 RX_RAWP.t0 RX_BW_EN_N.t1 a_484_3500.t0 VDD.t7 pfet_03v3 ad=2.2p pd=10.88u as=2.2p ps=10.88u w=5u l=0.28u
X123 a_n6400_n16252.t0 RXN.t0 VSS.t30 ppolyf_u r_width=1u r_length=1u
X124 XRX.XCAP.O_PRST_TAIL.t4 O_CAPTURE_CLKB.t12 VDD.t108 VDD.t107 pfet_03v3 ad=2.08p pd=8.52u as=2.08p ps=8.52u w=8u l=0.28u
X125 XRX.XFRONT.XFE_O.XN.t5 XRX.XFRONT.XFE_O.XP.t40 XRX.XFRONT.XFE_O.NIN.t0 VSS.t244 nfet_03v3 ad=2.08p pd=8.52u as=2.08p ps=8.52u w=8u l=0.28u
X126 a_n6400_n23452.t1 a_n10800_n23372.t2 a_n7157_n23500.t0 VSS.t258 nfet_03v3 ad=2.6p pd=10.52u as=4.4p ps=20.88u w=10u l=0.28u
X127 XRX.XFRONT.XFE_E.XP.t11 XRX.XFRONT.XFE_E.XN.t34 XRX.XFRONT.XFE_E.NIP.t13 VSS.t157 nfet_03v3 ad=2.08p pd=8.52u as=2.08p ps=8.52u w=8u l=0.28u
X128 VSS.t44 E_CAPTURE_CLK.t15 XRX.XCAP.E_SET_TAIL.t0 VSS.t43 nfet_03v3 ad=2.08p pd=8.52u as=3.52p ps=16.88u w=8u l=0.28u
X129 XRX.XFRONT.XFE_E.DP.t0 XRX.XFRONT.XFE_E.XP.t48 VDD.t22 VDD.t21 pfet_03v3 ad=2.08p pd=8.52u as=2.08p ps=8.52u w=8u l=0.28u
X130 a_74148_31500.t7 PHASE_B_P.t1 a_72404_31500.t2 VSS.t504 nfet_03v3 ad=1.3p pd=5.52u as=2.2p ps=10.88u w=5u l=0.28u
X131 VDD.t487 XRX.XFRONT.XFE_O.XP.t47 XRX.XFRONT.XFE_O.DP.t3 VDD.t486 pfet_03v3 ad=2.08p pd=8.52u as=2.08p ps=8.52u w=8u l=0.28u
X132 ODD_QB.t5 XRX.XCAP.O_QBUF.t5 VSS.t601 VSS.t600 nfet_03v3 ad=2.08p pd=8.52u as=2.08p ps=8.52u w=8u l=0.28u
X133 XRX.XCAP.O_SET_TAIL.t10 O_CAPTURE_CLK.t8 VSS.t212 VSS.t211 nfet_03v3 ad=3.52p pd=16.88u as=2.08p ps=8.52u w=8u l=0.28u
X134 XRX.XFRONT.XFE_O.HB.t3 XRX.XFRONT.XFE_O.DN.t12 VSS.t267 VSS.t266 nfet_03v3 ad=2.08p pd=8.52u as=2.08p ps=8.52u w=8u l=0.28u
X135 EVEN_Q.t1 XRX.XCAP.E_QBBUF.t7 VDD.t157 VDD.t156 pfet_03v3 ad=3.52p pd=16.88u as=2.08p ps=8.52u w=8u l=0.28u
X136 XRX.XCAP.E_QI.t1 XRX.XCAP.EVEN_DB_BUF.t18 XRX.XCAP.E_PSET_TAIL.t2 VDD.t99 pfet_03v3 ad=2.08p pd=8.52u as=2.08p ps=8.52u w=8u l=0.28u
X137 XRX.XFRONT.XFE_O.NTAIL.t22 O_SENSE_BOOST.t22 VSS.t545 VSS.t544 nfet_03v3 ad=2.6p pd=10.52u as=2.6p ps=10.52u w=10u l=0.28u
X138 RX_RAWN.t2 a_n3600_5641.t6 a_2148_n500.t0 VSS.t376 nfet_03v3 ad=2.2p pd=10.88u as=1.3p ps=5.52u w=5u l=0.28u
X139 VDD.t419 E_CAPTURE_CLKB.t11 XRX.XCAP.E_PRST_TAIL.t6 VDD.t261 pfet_03v3 ad=2.08p pd=8.52u as=2.08p ps=8.52u w=8u l=0.28u
X140 a_n1900_5958.t0 RX_BW_EN_N.t2 a_n3600_5641.t0 VDD.t6 pfet_03v3 ad=2.2p pd=10.88u as=2.2p ps=10.88u w=5u l=0.28u
X141 a_n6400_n12652.t1 TERM_EN6_N.t0 a_n7300_n12700.t1 VDD.t30 pfet_03v3 ad=2.6p pd=10.52u as=4.4p ps=20.88u w=10u l=0.28u
X142 XRX.XFRONT.XFE_E.NIN.t16 XRX.XFRONT.XFE_E.XP.t41 XRX.XFRONT.XFE_E.XN.t10 VSS.t189 nfet_03v3 ad=2.08p pd=8.52u as=2.08p ps=8.52u w=8u l=0.28u
X143 XRX.XCAP.E_RST_TAIL.t11 XRX.XCAP.EVEN_DB_BUF.t15 XRX.XCAP.E_QI.t4 VSS.t53 nfet_03v3 ad=2.08p pd=8.52u as=3.52p ps=16.88u w=8u l=0.28u
X144 VDD.t278 O_SENSE_CLK.t40 XRX.XFRONT.XFE_O.XP.t8 VDD.t277 pfet_03v3 ad=2.08p pd=8.52u as=3.52p ps=16.88u w=8u l=0.28u
X145 XRX.XFRONT.XFE_E.HB.t5 XRX.XFRONT.XFE_E.XP.t54 VDD.t161 VDD.t160 pfet_03v3 ad=2.08p pd=8.52u as=2.08p ps=8.52u w=8u l=0.28u
X146 XRX.XFRONT.XFE_E.NTAIL.t8 SAMP_E_P.t14 XRX.XFRONT.XFE_E.NIN.t3 VSS.t78 nfet_03v3 ad=2.08p pd=8.52u as=3.52p ps=16.88u w=8u l=0.28u
X147 XRX.XFRONT.XFE_O.XN.t16 O_SENSE_CLK.t24 XRX.XFRONT.XFE_O.XP.t22 VDD.t299 pfet_03v3 ad=2.08p pd=8.52u as=2.08p ps=8.52u w=8u l=0.28u
X148 VDD.t87 FE_E_P.t18 XRX.XCAP.EVEN_DB_BUF.t4 VDD.t86 pfet_03v3 ad=2.08p pd=8.52u as=3.52p ps=16.88u w=8u l=0.28u
X149 XRX.XCAP.EVEN_DB_BUF.t11 FE_E_P.t11 VDD.t95 VDD.t94 pfet_03v3 ad=3.52p pd=16.88u as=2.08p ps=8.52u w=8u l=0.28u
X150 FE_O_P.t3 XRX.XFRONT.XFE_O.H.t20 VSS.t238 VSS.t237 nfet_03v3 ad=2.08p pd=8.52u as=2.08p ps=8.52u w=8u l=0.28u
X151 XRX.XFRONT.XFE_E.NTAIL.t1 SAMP_E_N.t12 XRX.XFRONT.XFE_E.NIP.t2 VSS.t3 nfet_03v3 ad=2.08p pd=8.52u as=2.08p ps=8.52u w=8u l=0.28u
X152 XRX.XFRONT.XFE_O.NIN.t9 XRX.XFRONT.XFE_O.XP.t37 XRX.XFRONT.XFE_O.XN.t8 VSS.t352 nfet_03v3 ad=2.08p pd=8.52u as=2.08p ps=8.52u w=8u l=0.28u
X153 VDD.t76 FE_O_P.t12 XRX.XCAP.ODD_DB_BUF.t10 VDD.t75 pfet_03v3 ad=2.08p pd=8.52u as=2.08p ps=8.52u w=8u l=0.28u
X154 SAMP_E_N.t3 RX_RESTP.t5 a_948_44200.t3 VSS.t508 nfet_03v3 ad=2.64p pd=12.88u as=1.56p ps=6.52u w=6u l=0.28u
X155 FE_E_N.t6 XRX.XFRONT.XFE_E.H.t24 VDD.t437 VDD.t436 pfet_03v3 ad=2.08p pd=8.52u as=3.52p ps=16.88u w=8u l=0.28u
X156 RXP.t3 a_n7300_n12700.t2 VSS.t11 ppolyf_u r_width=1u r_length=1u
X157 a_65148_38800.t4 a_66600_32348.t4 PI_CLK_N.t1 VSS.t385 nfet_03v3 ad=2.6p pd=10.52u as=4.4p ps=20.88u w=10u l=0.28u
X158 XRX.XFRONT.XFE_O.XP.t7 XRX.XFRONT.XFE_O.XN.t38 XRX.XFRONT.XFE_O.NIP.t7 VSS.t166 nfet_03v3 ad=2.08p pd=8.52u as=2.08p ps=8.52u w=8u l=0.28u
X159 XRX.XCAP.E_RST_TAIL.t4 E_CAPTURE_CLK.t4 VSS.t63 VSS.t62 nfet_03v3 ad=2.08p pd=8.52u as=2.08p ps=8.52u w=8u l=0.28u
X160 a_n6400_n19852.t0 RXN.t2 VSS.t124 ppolyf_u r_width=1u r_length=1u
X161 VSS.t263 XRX.XFRONT.XFE_O.DN.t9 XRX.XFRONT.XFE_O.HB.t6 VSS.t262 nfet_03v3 ad=2.08p pd=8.52u as=2.08p ps=8.52u w=8u l=0.28u
X162 VSS.t549 O_SENSE_BOOST.t19 XRX.XFRONT.XFE_O.NTAIL.t25 VSS.t548 nfet_03v3 ad=2.6p pd=10.52u as=2.6p ps=10.52u w=10u l=0.28u
X163 a_n6572_3500.t0 RX_BW_EN_N.t3 a_n6716_3500.t0 VDD.t5 pfet_03v3 ad=2.2p pd=10.88u as=2.2p ps=10.88u w=5u l=0.28u
X164 a_72548_31500.t5 PI_CTRL_A.t2 VSS.t513 VSS.t229 nfet_03v3 ad=1.3p pd=5.52u as=1.3p ps=5.52u w=5u l=0.28u
X165 SAMP_O_N.t0 SAMP_O_P.t5 a_12148_44200.t3 VSS.t414 nfet_03v3 ad=2.64p pd=12.88u as=1.56p ps=6.52u w=6u l=0.28u
X166 VDD.t354 XRX.XCAP.O_QBUF.t10 ODD_QB.t0 VDD.t353 pfet_03v3 ad=2.08p pd=8.52u as=3.52p ps=16.88u w=8u l=0.28u
X167 XRX.XFRONT.XFE_E.H.t11 XRX.XFRONT.XFE_E.HB.t24 VDD.t253 VDD.t252 pfet_03v3 ad=2.08p pd=8.52u as=2.08p ps=8.52u w=8u l=0.28u
X168 VDD.t342 XRX.XFRONT.XFE_O.HB.t26 XRX.XFRONT.XFE_O.H.t3 VDD.t341 pfet_03v3 ad=2.08p pd=8.52u as=2.08p ps=8.52u w=8u l=0.28u
X169 VDD.t431 a_72404_31500.t4 VSS.t516 ppolyf_u r_width=2u r_length=4u
X170 VDD.t477 XRX.XCAP.E_QI.t19 XRX.XCAP.E_QBBUF.t2 VDD.t355 pfet_03v3 ad=2.08p pd=8.52u as=3.52p ps=16.88u w=8u l=0.28u
X171 a_65148_29400.t7 PI_RAW_N.t4 a_66600_32348.t1 VSS.t385 nfet_03v3 ad=2.6p pd=10.52u as=4.4p ps=20.88u w=10u l=0.28u
X172 XRX.XFRONT.XFE_O.XN.t29 O_SENSE_CLK.t7 VDD.t328 VDD.t327 pfet_03v3 ad=2.08p pd=8.52u as=2.08p ps=8.52u w=8u l=0.28u
X173 VDD.t441 XRX.XFRONT.XFE_E.H.t26 XRX.XFRONT.XFE_E.HB.t3 VDD.t440 pfet_03v3 ad=2.08p pd=8.52u as=2.08p ps=8.52u w=8u l=0.28u
X174 XRX.XCAP.O_SET_TAIL.t4 O_CAPTURE_CLK.t14 VSS.t204 VSS.t203 nfet_03v3 ad=2.08p pd=8.52u as=2.08p ps=8.52u w=8u l=0.28u
X175 VSS.t533 RX_BIAS.t2 a_2148_n500.t5 VSS.t517 nfet_03v3 ad=2.6p pd=10.52u as=2.6p ps=10.52u w=10u l=0.28u
X176 VDD.t245 SAMP_O_P.t0 VSS.t348 ppolyf_u r_width=2u r_length=5u
X177 XRX.XFRONT.XFE_E.XN.t24 E_SENSE_CLK.t31 VDD.t193 VDD.t192 pfet_03v3 ad=3.52p pd=16.88u as=2.08p ps=8.52u w=8u l=0.28u
X178 VDD.t227 E_SENSE_CLK.t10 XRX.XFRONT.XFE_E.XP.t26 VDD.t226 pfet_03v3 ad=2.08p pd=8.52u as=2.08p ps=8.52u w=8u l=0.28u
X179 VSS.t295 CLK_REST_BIAS.t1 a_65148_29400.t2 VSS.t289 nfet_03v3 ad=3.12p pd=12.52u as=3.12p ps=12.52u w=12u l=0.28u
X180 VDD.t120 O_CAPTURE_CLKB.t9 XRX.XCAP.O_PRST_TAIL.t7 VDD.t119 pfet_03v3 ad=2.08p pd=8.52u as=2.08p ps=8.52u w=8u l=0.28u
X181 VSS.t61 E_CAPTURE_CLK.t1 XRX.XCAP.E_RST_TAIL.t7 VSS.t60 nfet_03v3 ad=2.08p pd=8.52u as=2.08p ps=8.52u w=8u l=0.28u
X182 VDD.t215 E_SENSE_CLK.t16 XRX.XFRONT.XFE_E.NIP.t19 VDD.t214 pfet_03v3 ad=2.08p pd=8.52u as=2.08p ps=8.52u w=8u l=0.28u
X183 a_n10800_n16172.t1 TERM_EN4_N.t3 VDD.t18 VDD.t17 pfet_03v3 ad=0.88p pd=4.88u as=0.88p ps=4.88u w=2u l=0.28u
X184 VSS.t460 XRX.XFRONT.XFE_O.XN.t45 XRX.XFRONT.XFE_O.DN.t4 VSS.t459 nfet_03v3 ad=2.08p pd=8.52u as=3.52p ps=16.88u w=8u l=0.28u
X185 VSS.t430 XRX.XFRONT.XFE_O.HB.t20 FE_O_N.t1 VSS.t429 nfet_03v3 ad=2.08p pd=8.52u as=3.52p ps=16.88u w=8u l=0.28u
X186 XRX.XFRONT.XFE_E.NTAIL.t20 E_SENSE_CLK.t0 VSS.t283 VSS.t282 nfet_03v3 ad=4.4p pd=20.88u as=2.6p ps=10.52u w=10u l=0.28u
X187 a_n852_28800.t4 a_600_22678.t4 RX_RESTN.t1 VSS.t125 nfet_03v3 ad=2.6p pd=10.52u as=4.4p ps=20.88u w=10u l=0.28u
X188 VDD.t463 XRX.XCAP.E_QBBUF.t10 EVEN_Q.t5 VDD.t462 pfet_03v3 ad=2.08p pd=8.52u as=3.52p ps=16.88u w=8u l=0.28u
X189 XRX.XFRONT.XFE_O.NIN.t3 XRX.XFRONT.XFE_O.XP.t43 XRX.XFRONT.XFE_O.XN.t2 VSS.t247 nfet_03v3 ad=2.08p pd=8.52u as=3.52p ps=16.88u w=8u l=0.28u
X190 XRX.XCAP.E_PRST_TAIL.t9 E_CAPTURE_CLKB.t8 VDD.t406 VDD.t405 pfet_03v3 ad=3.52p pd=16.88u as=2.08p ps=8.52u w=8u l=0.28u
X191 VDD.t417 E_CAPTURE_CLKB.t15 XRX.XCAP.E_PRST_TAIL.t2 VDD.t416 pfet_03v3 ad=2.08p pd=8.52u as=3.52p ps=16.88u w=8u l=0.28u
X192 XRX.XCAP.O_QBBUF.t3 XRX.XCAP.O_QI.t18 VDD.t155 VDD.t39 pfet_03v3 ad=3.52p pd=16.88u as=2.08p ps=8.52u w=8u l=0.28u
X193 XRX.XCAP.E_SET_TAIL.t7 E_CAPTURE_CLK.t8 VSS.t46 VSS.t45 nfet_03v3 ad=3.52p pd=16.88u as=2.08p ps=8.52u w=8u l=0.28u
X194 PI_RAW_P.t2 a_72404_31500.t5 a_80148_31500.t3 VSS.t451 nfet_03v3 ad=2.2p pd=10.88u as=1.3p ps=5.52u w=5u l=0.28u
X195 XRX.XFRONT.XFE_E.NIP.t8 XRX.XFRONT.XFE_E.XN.t35 XRX.XFRONT.XFE_E.XP.t10 VSS.t74 nfet_03v3 ad=2.08p pd=8.52u as=2.08p ps=8.52u w=8u l=0.28u
X196 VSS.t207 O_CAPTURE_CLK.t11 XRX.XCAP.O_SET_TAIL.t7 VSS.t33 nfet_03v3 ad=2.08p pd=8.52u as=2.08p ps=8.52u w=8u l=0.28u
X197 XRX.XFRONT.XFE_O.NTAIL.t16 SAMP_O_N.t14 XRX.XFRONT.XFE_O.NIN.t16 VSS.t494 nfet_03v3 ad=2.08p pd=8.52u as=3.52p ps=16.88u w=8u l=0.28u
X198 VSS.t290 CLK_REST_BIAS.t5 a_65148_38800.t2 VSS.t289 nfet_03v3 ad=3.12p pd=12.52u as=3.12p ps=12.52u w=12u l=0.28u
X199 VSS.t367 O_SENSE_CLK.t4 XRX.XFRONT.XFE_O.NTAIL.t0 VSS.t366 nfet_03v3 ad=2.6p pd=10.52u as=4.4p ps=20.88u w=10u l=0.28u
X200 XRX.XCAP.EVEN_D_BUF.t9 FE_E_N.t13 VDD.t368 VDD.t367 pfet_03v3 ad=2.08p pd=8.52u as=2.08p ps=8.52u w=8u l=0.28u
X201 VDD.t294 O_SENSE_CLK.t32 XRX.XFRONT.XFE_O.XP.t16 VDD.t293 pfet_03v3 ad=2.08p pd=8.52u as=2.08p ps=8.52u w=8u l=0.28u
X202 VDD.t91 FE_E_P.t14 XRX.XCAP.EVEN_DB_BUF.t8 VDD.t90 pfet_03v3 ad=2.08p pd=8.52u as=2.08p ps=8.52u w=8u l=0.28u
X203 a_n852_19400.t5 RX_RAWN.t5 a_600_22678.t0 VSS.t125 nfet_03v3 ad=2.6p pd=10.52u as=4.4p ps=20.88u w=10u l=0.28u
X204 VDD.t68 FE_O_P.t16 XRX.XCAP.ODD_DB_BUF.t6 VDD.t67 pfet_03v3 ad=2.08p pd=8.52u as=2.08p ps=8.52u w=8u l=0.28u
X205 XRX.XFRONT.XFE_E.XN.t26 E_SENSE_CLK.t20 XRX.XFRONT.XFE_E.XP.t20 VDD.t208 pfet_03v3 ad=2.08p pd=8.52u as=2.08p ps=8.52u w=8u l=0.28u
X206 VDD.t449 XRX.XFRONT.XFE_E.XN.t47 XRX.XFRONT.XFE_E.DN.t5 VDD.t448 pfet_03v3 ad=2.08p pd=8.52u as=2.08p ps=8.52u w=8u l=0.28u
X207 XRX.XCAP.O_RST_TAIL.t3 XRX.XCAP.ODD_DB_BUF.t15 XRX.XCAP.O_QI.t5 VSS.t77 nfet_03v3 ad=2.08p pd=8.52u as=3.52p ps=16.88u w=8u l=0.28u
X208 VDD.t147 PI_RAW_N.t2 VSS.t186 ppolyf_u r_width=2u r_length=5.25u
X209 FE_O_N.t3 XRX.XFRONT.XFE_O.HB.t17 VSS.t447 VSS.t446 nfet_03v3 ad=3.52p pd=16.88u as=2.08p ps=8.52u w=8u l=0.28u
X210 a_n6400_n16252.t2 TERM_EN4_N.t0 a_n7300_n16300.t1 VDD.t20 pfet_03v3 ad=2.6p pd=10.52u as=4.4p ps=20.88u w=10u l=0.28u
X211 a_2548_44200.t5 PI_CLK_N.t5 a_2148_41600.t6 VSS.t175 nfet_03v3 ad=3.52p pd=16.88u as=2.08p ps=8.52u w=8u l=0.28u
X212 XRX.XCAP.O_QI.t9 XRX.XCAP.ODD_DB_BUF.t18 XRX.XCAP.O_PSET_TAIL.t3 VDD.t98 pfet_03v3 ad=2.08p pd=8.52u as=2.08p ps=8.52u w=8u l=0.28u
X213 VSS.t490 XRX.XCAP.E_QBUF.t6 EVEN_QB.t3 VSS.t489 nfet_03v3 ad=2.08p pd=8.52u as=3.52p ps=16.88u w=8u l=0.28u
X214 XRX.XFRONT.XFE_E.NIP.t5 SAMP_E_N.t9 XRX.XFRONT.XFE_E.NTAIL.t6 VSS.t6 nfet_03v3 ad=2.08p pd=8.52u as=2.08p ps=8.52u w=8u l=0.28u
X215 VDD.t127 O_CAPTURE_CLKB.t3 XRX.XCAP.O_PSET_TAIL.t8 VDD.t109 pfet_03v3 ad=2.08p pd=8.52u as=2.08p ps=8.52u w=8u l=0.28u
X216 a_n10800_n19772.t1 TERM_EN2_N.t3 VDD.t335 VDD.t334 pfet_03v3 ad=0.88p pd=4.88u as=0.88p ps=4.88u w=2u l=0.28u
X217 XRX.XFRONT.XFE_O.XP.t29 XRX.XFRONT.XFE_O.XN.t50 VDD.t384 VDD.t383 pfet_03v3 ad=3.52p pd=16.88u as=2.08p ps=8.52u w=8u l=0.28u
X218 VSS.t257 XRX.XFRONT.XFE_E.DN.t9 XRX.XFRONT.XFE_E.HB.t11 VSS.t256 nfet_03v3 ad=2.08p pd=8.52u as=2.08p ps=8.52u w=8u l=0.28u
X219 VDD.t340 XRX.XCAP.E_QBI.t17 XRX.XCAP.E_QI.t9 VDD.t99 pfet_03v3 ad=2.08p pd=8.52u as=3.52p ps=16.88u w=8u l=0.28u
X220 XRX.XCAP.E_QI.t3 XRX.XCAP.EVEN_DB_BUF.t16 XRX.XCAP.E_PSET_TAIL.t0 VDD.t58 pfet_03v3 ad=3.52p pd=16.88u as=2.08p ps=8.52u w=8u l=0.28u
X221 a_74148_31500.t3 PI_CTRL_B.t2 VSS.t230 VSS.t229 nfet_03v3 ad=1.3p pd=5.52u as=1.3p ps=5.52u w=5u l=0.28u
X222 XRX.XFRONT.XFE_E.XP.t7 XRX.XFRONT.XFE_E.XN.t38 XRX.XFRONT.XFE_E.NIP.t14 VSS.t224 nfet_03v3 ad=2.08p pd=8.52u as=2.08p ps=8.52u w=8u l=0.28u
X223 a_11748_41600.t1 SAMP_BIAS.t2 VSS.t25 VSS.t24 nfet_03v3 ad=2.6p pd=10.52u as=2.6p ps=10.52u w=10u l=0.28u
X224 XRX.XFRONT.XFE_O.NTAIL.t3 O_SENSE_CLK.t1 VSS.t375 VSS.t374 nfet_03v3 ad=2.6p pd=10.52u as=2.6p ps=10.52u w=10u l=0.28u
X225 RXP.t2 a_n7300_n16300.t2 VSS.t11 ppolyf_u r_width=1u r_length=1u
X226 XRX.XCAP.E_PSET_TAIL.t9 E_CAPTURE_CLKB.t2 VDD.t412 VDD.t411 pfet_03v3 ad=2.08p pd=8.52u as=2.08p ps=8.52u w=8u l=0.28u
X227 VSS.t148 FE_E_P.t8 XRX.XCAP.EVEN_DB_BUF.t2 VSS.t147 nfet_03v3 ad=2.08p pd=8.52u as=2.08p ps=8.52u w=8u l=0.28u
X228 XRX.XFRONT.XFE_E.XP.t17 E_SENSE_CLK.t23 XRX.XFRONT.XFE_E.XN.t12 VDD.t205 pfet_03v3 ad=2.08p pd=8.52u as=2.08p ps=8.52u w=8u l=0.28u
X229 XRX.XCAP.O_QI.t0 XRX.XCAP.ODD_DB_BUF.t12 XRX.XCAP.O_RST_TAIL.t0 VSS.t31 nfet_03v3 ad=3.52p pd=16.88u as=2.08p ps=8.52u w=8u l=0.28u
X230 VDD.t114 O_CAPTURE_CLKB.t13 XRX.XCAP.O_PRST_TAIL.t3 VDD.t113 pfet_03v3 ad=2.08p pd=8.52u as=2.08p ps=8.52u w=8u l=0.28u
X231 XRX.XFRONT.XFE_E.NTAIL.t26 E_SENSE_BOOST.t18 VSS.t304 VSS.t303 nfet_03v3 ad=2.6p pd=10.52u as=2.6p ps=10.52u w=10u l=0.28u
X232 VDD.t322 O_SENSE_CLK.t10 XRX.XFRONT.XFE_O.XN.t26 VDD.t321 pfet_03v3 ad=2.08p pd=8.52u as=2.08p ps=8.52u w=8u l=0.28u
X233 XRX.XFRONT.XFE_E.H.t14 XRX.XFRONT.XFE_E.XN.t50 VDD.t350 VDD.t349 pfet_03v3 ad=3.52p pd=16.88u as=2.08p ps=8.52u w=8u l=0.28u
X234 XRX.XFRONT.XFE_E.XP.t29 E_SENSE_CLK.t7 VDD.t233 VDD.t232 pfet_03v3 ad=2.08p pd=8.52u as=2.08p ps=8.52u w=8u l=0.28u
X235 VDD.t286 O_SENSE_CLK.t38 XRX.XFRONT.XFE_O.XP.t10 VDD.t285 pfet_03v3 ad=2.08p pd=8.52u as=2.08p ps=8.52u w=8u l=0.28u
X236 XRX.XFRONT.XFE_E.HB.t8 XRX.XFRONT.XFE_E.DN.t12 VSS.t453 VSS.t452 nfet_03v3 ad=2.08p pd=8.52u as=2.08p ps=8.52u w=8u l=0.28u
X237 a_n5052_2600.t7 RX_BIAS.t10 VSS.t528 VSS.t526 nfet_03v3 ad=0.88p pd=4.88u as=0.52p ps=2.52u w=2u l=0.28u
X238 a_n6572_3500.t2 RXP.t8 a_n5052_n1000.t2 VSS.t377 nfet_03v3 ad=4.4p pd=20.88u as=2.6p ps=10.52u w=10u l=0.28u
X239 a_n6400_n19852.t3 TERM_EN2_N.t0 a_n7300_n19900.t3 VDD.t337 pfet_03v3 ad=2.6p pd=10.52u as=4.4p ps=20.88u w=10u l=0.28u
X240 a_n3600_5641.t3 VTHN.t0 a_n5052_2600.t0 VSS.t350 nfet_03v3 ad=0.88p pd=4.88u as=0.52p ps=2.52u w=2u l=0.28u
X241 XRX.XFRONT.XFE_O.NTAIL.t36 O_SENSE_BOOST.t8 VSS.t567 VSS.t566 nfet_03v3 ad=2.6p pd=10.52u as=2.6p ps=10.52u w=10u l=0.28u
X242 VSS.t440 XRX.XFRONT.XFE_O.DP.t13 XRX.XFRONT.XFE_O.H.t5 VSS.t439 nfet_03v3 ad=2.08p pd=8.52u as=3.52p ps=16.88u w=8u l=0.28u
X243 XRX.XFRONT.XFE_O.NTAIL.t11 SAMP_O_P.t12 XRX.XFRONT.XFE_O.NIP.t14 VSS.t407 nfet_03v3 ad=2.08p pd=8.52u as=2.08p ps=8.52u w=8u l=0.28u
X244 VSS.t583 XRX.XFRONT.XFE_E.XN.t45 XRX.XFRONT.XFE_E.DN.t3 VSS.t299 nfet_03v3 ad=2.08p pd=8.52u as=3.52p ps=16.88u w=8u l=0.28u
X245 XRX.XFRONT.XFE_O.NIN.t7 XRX.XFRONT.XFE_O.XP.t35 XRX.XFRONT.XFE_O.XN.t10 VSS.t273 nfet_03v3 ad=2.08p pd=8.52u as=2.08p ps=8.52u w=8u l=0.28u
X246 FE_O_P.t0 XRX.XFRONT.XFE_O.H.t27 VDD.t150 VDD.t149 pfet_03v3 ad=2.08p pd=8.52u as=2.08p ps=8.52u w=8u l=0.28u
X247 XRX.XCAP.EVEN_D_BUF.t7 FE_E_N.t15 VDD.t356 VDD.t355 pfet_03v3 ad=2.08p pd=8.52u as=2.08p ps=8.52u w=8u l=0.28u
X248 VSS.t599 XRX.XCAP.O_QBBUF.t4 ODD_Q.t4 VSS.t598 nfet_03v3 ad=3.52p pd=16.88u as=2.08p ps=8.52u w=8u l=0.28u
X249 a_n7157_n23500.t1 TERM_EN0_N.t1 a_n6400_n23452.t3 VDD.t248 pfet_03v3 ad=4.4p pd=20.88u as=2.6p ps=10.52u w=10u l=0.28u
X250 RXP.t1 a_n7300_n19900.t0 VSS.t11 ppolyf_u r_width=1u r_length=1u
X251 VSS.t468 XRX.XFRONT.XFE_O.DN.t7 XRX.XFRONT.XFE_O.HB.t8 VSS.t467 nfet_03v3 ad=2.08p pd=8.52u as=2.08p ps=8.52u w=8u l=0.28u
X252 VSS.t302 E_SENSE_BOOST.t21 XRX.XFRONT.XFE_E.NTAIL.t23 VSS.t301 nfet_03v3 ad=2.6p pd=10.52u as=2.6p ps=10.52u w=10u l=0.28u
X253 a_11748_41600.t7 PI_CLK_N.t4 a_10548_44200.t0 VSS.t176 nfet_03v3 ad=2.08p pd=8.52u as=3.52p ps=16.88u w=8u l=0.28u
X254 VDD.t47 RX_RAWN.t1 VSS.t122 ppolyf_u r_width=2u r_length=3.43u
X255 VSS.t96 REST_BIAS.t3 a_n852_19400.t0 VSS.t88 nfet_03v3 ad=3.12p pd=12.52u as=5.28p ps=24.88u w=12u l=0.28u
X256 XRX.XFRONT.XFE_O.XP.t13 O_SENSE_CLK.t35 VDD.t284 VDD.t283 pfet_03v3 ad=2.08p pd=8.52u as=2.08p ps=8.52u w=8u l=0.28u
X257 a_n7300_n14500.t4 a_n10800_n14372.t3 a_n6400_n14452.t4 VSS.t384 nfet_03v3 ad=4.4p pd=20.88u as=2.6p ps=10.52u w=10u l=0.28u
X258 XRX.XCAP.O_PSET_TAIL.t11 O_CAPTURE_CLKB.t0 VDD.t130 VDD.t121 pfet_03v3 ad=3.52p pd=16.88u as=2.08p ps=8.52u w=8u l=0.28u
X259 FE_E_P.t0 XRX.XFRONT.XFE_E.HB.t20 VSS.t361 VSS.t360 nfet_03v3 ad=2.08p pd=8.52u as=2.08p ps=8.52u w=8u l=0.28u
X260 VDD.t123 O_CAPTURE_CLKB.t7 XRX.XCAP.O_PSET_TAIL.t4 VDD.t111 pfet_03v3 ad=2.08p pd=8.52u as=3.52p ps=16.88u w=8u l=0.28u
X261 a_n10800_n12572.t0 TERM_EN6_N.t2 VSS.t112 VSS.t41 nfet_03v3 ad=0.44p pd=2.88u as=0.44p ps=2.88u w=1u l=0.28u
X262 VSS.t571 O_SENSE_BOOST.t5 XRX.XFRONT.XFE_O.NTAIL.t39 VSS.t570 nfet_03v3 ad=2.6p pd=10.52u as=2.6p ps=10.52u w=10u l=0.28u
X263 XRX.XFRONT.XFE_O.XP.t20 O_SENSE_CLK.t19 XRX.XFRONT.XFE_O.XN.t21 VDD.t304 pfet_03v3 ad=3.52p pd=16.88u as=2.08p ps=8.52u w=8u l=0.28u
X264 VSS.t522 RX_BIAS.t0 a_2148_n500.t7 VSS.t517 nfet_03v3 ad=4.4p pd=20.88u as=2.6p ps=10.52u w=10u l=0.28u
X265 XRX.XFRONT.XFE_O.XN.t13 XRX.XFRONT.XFE_O.XP.t32 XRX.XFRONT.XFE_O.NIN.t4 VSS.t270 nfet_03v3 ad=3.52p pd=16.88u as=2.08p ps=8.52u w=8u l=0.28u
X266 XRX.XFRONT.XFE_E.XN.t5 XRX.XFRONT.XFE_E.XP.t34 XRX.XFRONT.XFE_E.NIN.t11 VSS.t109 nfet_03v3 ad=2.08p pd=8.52u as=2.08p ps=8.52u w=8u l=0.28u
X267 XRX.XFRONT.XFE_O.HB.t12 XRX.XFRONT.XFE_O.H.t24 VDD.t467 VDD.t466 pfet_03v3 ad=2.08p pd=8.52u as=2.08p ps=8.52u w=8u l=0.28u
X268 VDD.t40 FE_O_N.t14 XRX.XCAP.ODD_D_BUF.t8 VDD.t39 pfet_03v3 ad=2.08p pd=8.52u as=2.08p ps=8.52u w=8u l=0.28u
X269 XRX.XFRONT.XFE_E.XN.t22 E_SENSE_CLK.t33 VDD.t191 VDD.t190 pfet_03v3 ad=2.08p pd=8.52u as=2.08p ps=8.52u w=8u l=0.28u
X270 XRX.XFRONT.XFE_E.HB.t0 XRX.XFRONT.XFE_E.H.t21 VSS.t185 VSS.t184 nfet_03v3 ad=3.52p pd=16.88u as=3.52p ps=16.88u w=8u l=0.28u
X271 a_n10800_n21572.t1 TERM_EN1_N.t3 VDD.t10 VDD.t9 pfet_03v3 ad=0.88p pd=4.88u as=0.88p ps=4.88u w=2u l=0.28u
X272 VSS.t36 XRX.XCAP.O_QBI.t13 XRX.XCAP.O_QI.t2 VSS.t35 nfet_03v3 ad=2.08p pd=8.52u as=3.52p ps=16.88u w=8u l=0.28u
X273 XRX.XFRONT.XFE_O.NIP.t21 XRX.XFRONT.XFE_O.XN.t33 XRX.XFRONT.XFE_O.XP.t27 VSS.t442 nfet_03v3 ad=2.08p pd=8.52u as=2.08p ps=8.52u w=8u l=0.28u
X274 XRX.XCAP.E_QBBUF.t1 XRX.XCAP.E_QI.t14 VSS.t493 VSS.t419 nfet_03v3 ad=1.76p pd=8.88u as=1.04p ps=4.52u w=4u l=0.28u
X275 VDD.t213 E_SENSE_CLK.t18 XRX.XFRONT.XFE_E.NIP.t17 VDD.t212 pfet_03v3 ad=2.08p pd=8.52u as=3.52p ps=16.88u w=8u l=0.28u
X276 XRX.XFRONT.XFE_E.HB.t14 XRX.XFRONT.XFE_E.DN.t6 VSS.t480 VSS.t479 nfet_03v3 ad=3.52p pd=16.88u as=2.08p ps=8.52u w=8u l=0.28u
X277 VSS.t527 RX_BIAS.t11 a_n5052_2600.t6 VSS.t526 nfet_03v3 ad=0.52p pd=2.52u as=0.52p ps=2.52u w=2u l=0.28u
X278 a_n5052_n1000.t3 RXP.t9 a_n6572_3500.t1 VSS.t377 nfet_03v3 ad=2.6p pd=10.52u as=4.4p ps=20.88u w=10u l=0.28u
X279 XRX.XFRONT.XFE_E.NTAIL.t44 E_SENSE_BOOST.t0 VSS.t344 VSS.t343 nfet_03v3 ad=4.4p pd=20.88u as=2.6p ps=10.52u w=10u l=0.28u
X280 VSS.t626 XRX.XCAP.O_QI.t15 XRX.XCAP.O_QBBUF.t0 VSS.t115 nfet_03v3 ad=1.04p pd=4.52u as=1.76p ps=8.88u w=4u l=0.28u
X281 XRX.XFRONT.XFE_O.NTAIL.t30 O_SENSE_BOOST.t14 VSS.t555 VSS.t554 nfet_03v3 ad=2.6p pd=10.52u as=2.6p ps=10.52u w=10u l=0.28u
X282 XRX.XFRONT.XFE_E.NTAIL.t18 E_SENSE_CLK.t2 VSS.t279 VSS.t278 nfet_03v3 ad=2.6p pd=10.52u as=2.6p ps=10.52u w=10u l=0.28u
X283 VDD.t392 XRX.XFRONT.XFE_O.HB.t24 FE_O_N.t6 VDD.t391 pfet_03v3 ad=2.08p pd=8.52u as=3.52p ps=16.88u w=8u l=0.28u
X284 VSS.t396 XRX.XCAP.E_QBI.t13 XRX.XCAP.E_QI.t11 VSS.t47 nfet_03v3 ad=2.08p pd=8.52u as=3.52p ps=16.88u w=8u l=0.28u
X285 VSS.t89 REST_BIAS.t7 a_n852_28800.t0 VSS.t88 nfet_03v3 ad=3.12p pd=12.52u as=5.28p ps=24.88u w=12u l=0.28u
X286 XRX.XCAP.O_QBUF.t0 XRX.XCAP.O_QBI.t18 VDD.t165 VDD.t164 pfet_03v3 ad=3.52p pd=16.88u as=2.08p ps=8.52u w=8u l=0.28u
X287 VSS.t455 XRX.XFRONT.XFE_E.DP.t13 XRX.XFRONT.XFE_E.H.t2 VSS.t454 nfet_03v3 ad=2.08p pd=8.52u as=3.52p ps=16.88u w=8u l=0.28u
X288 XRX.XCAP.E_SET_TAIL.t5 E_CAPTURE_CLK.t10 VSS.t57 VSS.t32 nfet_03v3 ad=2.08p pd=8.52u as=2.08p ps=8.52u w=8u l=0.28u
X289 VSS.t589 XRX.XFRONT.XFE_O.H.t17 XRX.XFRONT.XFE_O.HB.t10 VSS.t588 nfet_03v3 ad=3.52p pd=16.88u as=3.52p ps=16.88u w=8u l=0.28u
X290 XRX.XCAP.E_QBI.t11 XRX.XCAP.EVEN_D_BUF.t18 XRX.XCAP.E_PRST_TAIL.t11 VDD.t99 pfet_03v3 ad=2.08p pd=8.52u as=2.08p ps=8.52u w=8u l=0.28u
X291 VDD.t159 XRX.XCAP.O_QBI.t17 XRX.XCAP.O_QI.t11 VDD.t98 pfet_03v3 ad=2.08p pd=8.52u as=3.52p ps=16.88u w=8u l=0.28u
X292 VDD.t475 XRX.XFRONT.XFE_E.XP.t47 XRX.XFRONT.XFE_E.DP.t5 VDD.t474 pfet_03v3 ad=2.08p pd=8.52u as=2.08p ps=8.52u w=8u l=0.28u
X293 XRX.XCAP.O_QBI.t5 XRX.XCAP.O_QI.t16 VDD.t153 VDD.t109 pfet_03v3 ad=3.52p pd=16.88u as=2.08p ps=8.52u w=8u l=0.28u
X294 XRX.XFRONT.XFE_O.NTAIL.t18 SAMP_O_N.t12 XRX.XFRONT.XFE_O.NIN.t18 VSS.t496 nfet_03v3 ad=2.08p pd=8.52u as=2.08p ps=8.52u w=8u l=0.28u
X295 VSS.t316 E_SENSE_BOOST.t15 XRX.XFRONT.XFE_E.NTAIL.t29 VSS.t315 nfet_03v3 ad=2.6p pd=10.52u as=2.6p ps=10.52u w=10u l=0.28u
X296 a_n7300_n18100.t2 a_n10800_n17972.t3 a_n6400_n18052.t2 VSS.t483 nfet_03v3 ad=4.4p pd=20.88u as=2.6p ps=10.52u w=10u l=0.28u
X297 VDD.t175 E_SENSE_CLK.t36 XRX.XFRONT.XFE_E.XN.t19 VDD.t174 pfet_03v3 ad=2.08p pd=8.52u as=2.08p ps=8.52u w=8u l=0.28u
X298 VSS.t13 SAMP_BIAS.t7 a_2148_41600.t0 VSS.t12 nfet_03v3 ad=2.6p pd=10.52u as=4.4p ps=20.88u w=10u l=0.28u
X299 a_75604_31500.t3 PHASE_B_N.t0 a_74148_31500.t1 VSS.t106 nfet_03v3 ad=2.2p pd=10.88u as=1.3p ps=5.52u w=5u l=0.28u
X300 VDD.t445 XRX.XCAP.O_QBUF.t8 ODD_QB.t3 VDD.t444 pfet_03v3 ad=2.08p pd=8.52u as=2.08p ps=8.52u w=8u l=0.28u
X301 a_n6400_n21652.t0 TERM_EN1_N.t0 a_n7157_n21700.t2 VDD.t12 pfet_03v3 ad=2.6p pd=10.52u as=4.4p ps=20.88u w=10u l=0.28u
X302 a_n6400_n21652.t4 RXN.t6 VSS.t506 ppolyf_u r_width=1u r_length=2.43u
X303 VSS.t563 O_SENSE_BOOST.t11 XRX.XFRONT.XFE_O.NTAIL.t33 VSS.t562 nfet_03v3 ad=2.6p pd=10.52u as=2.6p ps=10.52u w=10u l=0.28u
X304 XRX.XFRONT.XFE_O.XP.t21 O_SENSE_CLK.t25 XRX.XFRONT.XFE_O.XN.t15 VDD.t298 pfet_03v3 ad=2.08p pd=8.52u as=2.08p ps=8.52u w=8u l=0.28u
X305 XRX.XFRONT.XFE_O.XN.t7 XRX.XFRONT.XFE_O.XP.t38 XRX.XFRONT.XFE_O.NIN.t10 VSS.t353 nfet_03v3 ad=2.08p pd=8.52u as=2.08p ps=8.52u w=8u l=0.28u
X306 a_948_44200.t2 RX_RESTP.t6 SAMP_E_N.t2 VSS.t507 nfet_03v3 ad=1.56p pd=6.52u as=2.64p ps=12.88u w=6u l=0.28u
X307 XRX.XFRONT.XFE_O.NIP.t11 O_SENSE_CLK.t27 VDD.t274 VDD.t273 pfet_03v3 ad=3.52p pd=16.88u as=2.08p ps=8.52u w=8u l=0.28u
X308 a_n6400_n12652.t3 a_n10800_n12572.t2 a_n7300_n12700.t3 VSS.t388 nfet_03v3 ad=2.6p pd=10.52u as=4.4p ps=20.88u w=10u l=0.28u
X309 FE_E_N.t5 XRX.XFRONT.XFE_E.H.t19 VSS.t198 VSS.t197 nfet_03v3 ad=2.08p pd=8.52u as=2.08p ps=8.52u w=8u l=0.28u
X310 VDD.t145 XRX.XCAP.E_QBUF.t8 EVEN_QB.t2 VDD.t144 pfet_03v3 ad=2.08p pd=8.52u as=2.08p ps=8.52u w=8u l=0.28u
X311 a_948_44200.t4 RX_RESTN.t6 SAMP_E_P.t3 VSS.t618 nfet_03v3 ad=1.56p pd=6.52u as=2.64p ps=12.88u w=6u l=0.28u
X312 XRX.XFRONT.XFE_O.HB.t5 XRX.XFRONT.XFE_O.DN.t10 VSS.t464 VSS.t463 nfet_03v3 ad=2.08p pd=8.52u as=2.08p ps=8.52u w=8u l=0.28u
X313 XRX.XFRONT.XFE_O.NIN.t21 SAMP_O_N.t9 XRX.XFRONT.XFE_O.NTAIL.t13 VSS.t499 nfet_03v3 ad=2.08p pd=8.52u as=2.08p ps=8.52u w=8u l=0.28u
X314 EVEN_Q.t3 XRX.XCAP.E_QBBUF.t5 VSS.t482 VSS.t481 nfet_03v3 ad=2.08p pd=8.52u as=2.08p ps=8.52u w=8u l=0.28u
X315 a_2148_41600.t3 SAMP_BIAS.t4 VSS.t15 VSS.t14 nfet_03v3 ad=4.4p pd=20.88u as=2.6p ps=10.52u w=10u l=0.28u
X316 a_12148_44200.t2 SAMP_O_P.t6 SAMP_O_N.t2 VSS.t413 nfet_03v3 ad=1.56p pd=6.52u as=2.64p ps=12.88u w=6u l=0.28u
X317 VDD.t251 XRX.XFRONT.XFE_E.HB.t23 XRX.XFRONT.XFE_E.H.t10 VDD.t250 pfet_03v3 ad=2.08p pd=8.52u as=2.08p ps=8.52u w=8u l=0.28u
X318 XRX.XCAP.ODD_D_BUF.t11 FE_O_N.t11 VDD.t46 VDD.t45 pfet_03v3 ad=3.52p pd=16.88u as=2.08p ps=8.52u w=8u l=0.28u
X319 VDD.t32 FE_O_N.t18 XRX.XCAP.ODD_D_BUF.t4 VDD.t31 pfet_03v3 ad=2.08p pd=8.52u as=3.52p ps=16.88u w=8u l=0.28u
X320 XRX.XFRONT.XFE_O.XN.t18 O_SENSE_CLK.t22 XRX.XFRONT.XFE_O.XP.t24 VDD.t301 pfet_03v3 ad=2.08p pd=8.52u as=2.08p ps=8.52u w=8u l=0.28u
X321 XRX.XFRONT.XFE_E.NTAIL.t7 SAMP_E_N.t14 XRX.XFRONT.XFE_E.NIP.t0 VSS.t1 nfet_03v3 ad=2.08p pd=8.52u as=3.52p ps=16.88u w=8u l=0.28u
X322 VSS.t172 XRX.XFRONT.XFE_E.XP.t45 XRX.XFRONT.XFE_E.DP.t3 VSS.t171 nfet_03v3 ad=2.08p pd=8.52u as=3.52p ps=16.88u w=8u l=0.28u
X323 XRX.XFRONT.XFE_O.DP.t0 XRX.XFRONT.XFE_O.XP.t44 VSS.t249 VSS.t248 nfet_03v3 ad=3.52p pd=16.88u as=2.08p ps=8.52u w=8u l=0.28u
X324 XRX.XFRONT.XFE_E.XP.t27 E_SENSE_CLK.t9 VDD.t229 VDD.t228 pfet_03v3 ad=2.08p pd=8.52u as=2.08p ps=8.52u w=8u l=0.28u
X325 a_n10800_n16172.t0 TERM_EN4_N.t2 VSS.t107 VSS.t41 nfet_03v3 ad=0.44p pd=2.88u as=0.44p ps=2.88u w=1u l=0.28u
X326 VSS.t114 FE_O_N.t10 XRX.XCAP.ODD_D_BUF.t0 VSS.t113 nfet_03v3 ad=2.08p pd=8.52u as=3.52p ps=16.88u w=8u l=0.28u
X327 VDD.t72 FE_O_P.t14 XRX.XCAP.ODD_DB_BUF.t8 VDD.t71 pfet_03v3 ad=2.08p pd=8.52u as=2.08p ps=8.52u w=8u l=0.28u
X328 XRX.XFRONT.XFE_E.NIP.t20 E_SENSE_CLK.t15 VDD.t217 VDD.t216 pfet_03v3 ad=3.52p pd=16.88u as=2.08p ps=8.52u w=8u l=0.28u
X329 SAMP_E_P.t1 SAMP_E_N.t5 a_2548_44200.t1 VSS.t10 nfet_03v3 ad=2.64p pd=12.88u as=1.56p ps=6.52u w=6u l=0.28u
X330 XRX.XFRONT.XFE_E.NIP.t23 XRX.XFRONT.XFE_E.XN.t43 XRX.XFRONT.XFE_E.XP.t2 VSS.t486 nfet_03v3 ad=2.08p pd=8.52u as=3.52p ps=16.88u w=8u l=0.28u
X331 VSS.t537 O_SENSE_BOOST.t17 XRX.XFRONT.XFE_O.NTAIL.t27 VSS.t536 nfet_03v3 ad=2.6p pd=10.52u as=2.6p ps=10.52u w=10u l=0.28u
X332 XRX.XCAP.E_QBUF.t0 XRX.XCAP.E_QBI.t18 VDD.t459 VDD.t458 pfet_03v3 ad=3.52p pd=16.88u as=2.08p ps=8.52u w=8u l=0.28u
X333 XRX.XCAP.ODD_DB_BUF.t3 FE_O_P.t7 VSS.t143 VSS.t142 nfet_03v3 ad=3.52p pd=16.88u as=2.08p ps=8.52u w=8u l=0.28u
X334 XRX.XCAP.O_QBI.t11 XRX.XCAP.ODD_D_BUF.t12 XRX.XCAP.O_SET_TAIL.t11 VSS.t218 nfet_03v3 ad=3.52p pd=16.88u as=2.08p ps=8.52u w=8u l=0.28u
X335 XRX.XFRONT.XFE_E.NIN.t12 XRX.XFRONT.XFE_E.XP.t35 XRX.XFRONT.XFE_E.XN.t6 VSS.t110 nfet_03v3 ad=2.08p pd=8.52u as=2.08p ps=8.52u w=8u l=0.28u
X336 VSS.t59 E_CAPTURE_CLK.t9 XRX.XCAP.E_SET_TAIL.t6 VSS.t58 nfet_03v3 ad=2.08p pd=8.52u as=2.08p ps=8.52u w=8u l=0.28u
X337 XRX.XFRONT.XFE_O.XN.t31 O_SENSE_CLK.t5 VDD.t332 VDD.t331 pfet_03v3 ad=3.52p pd=16.88u as=2.08p ps=8.52u w=8u l=0.28u
X338 VDD.t382 XRX.XFRONT.XFE_E.H.t28 XRX.XFRONT.XFE_E.HB.t1 VDD.t381 pfet_03v3 ad=2.08p pd=8.52u as=3.52p ps=16.88u w=8u l=0.28u
X339 a_80148_31500.t2 a_72404_31500.t6 PI_RAW_P.t1 VSS.t392 nfet_03v3 ad=1.3p pd=5.52u as=2.2p ps=10.88u w=5u l=0.28u
X340 SAMP_O_P.t3 RX_RESTN.t3 a_10548_44200.t5 VSS.t621 nfet_03v3 ad=2.64p pd=12.88u as=1.56p ps=6.52u w=6u l=0.28u
X341 VSS.t306 E_SENSE_BOOST.t23 XRX.XFRONT.XFE_E.NTAIL.t21 VSS.t305 nfet_03v3 ad=2.6p pd=10.52u as=4.4p ps=20.88u w=10u l=0.28u
X342 XRX.XCAP.O_SET_TAIL.t6 O_CAPTURE_CLK.t12 VSS.t206 VSS.t35 nfet_03v3 ad=2.08p pd=8.52u as=2.08p ps=8.52u w=8u l=0.28u
X343 VDD.t308 O_SENSE_CLK.t18 XRX.XFRONT.XFE_O.NIN.t12 VDD.t307 pfet_03v3 ad=2.08p pd=8.52u as=3.52p ps=16.88u w=8u l=0.28u
X344 a_80148_31500.t7 PI_BUF_BIAS.t0 VSS.t617 VSS.t616 nfet_03v3 ad=4.4p pd=20.88u as=2.6p ps=10.52u w=10u l=0.28u
X345 VDD.t223 E_SENSE_CLK.t12 XRX.XFRONT.XFE_E.XP.t24 VDD.t222 pfet_03v3 ad=2.08p pd=8.52u as=2.08p ps=8.52u w=8u l=0.28u
X346 a_2148_n500.t2 a_n3600_5641.t7 RX_RAWN.t3 VSS.t376 nfet_03v3 ad=1.3p pd=5.52u as=2.2p ps=10.88u w=5u l=0.28u
X347 XRX.XCAP.ODD_D_BUF.t3 FE_O_N.t7 VSS.t120 VSS.t119 nfet_03v3 ad=3.52p pd=16.88u as=2.08p ps=8.52u w=8u l=0.28u
X348 XRX.XCAP.E_QBBUF.t3 XRX.XCAP.E_QI.t18 VDD.t476 VDD.t357 pfet_03v3 ad=3.52p pd=16.88u as=2.08p ps=8.52u w=8u l=0.28u
X349 VSS.t573 O_SENSE_BOOST.t3 XRX.XFRONT.XFE_O.NTAIL.t41 VSS.t572 nfet_03v3 ad=2.6p pd=10.52u as=2.6p ps=10.52u w=10u l=0.28u
X350 XRX.XFRONT.XFE_O.H.t10 XRX.XFRONT.XFE_O.DP.t8 VSS.t394 VSS.t393 nfet_03v3 ad=2.08p pd=8.52u as=2.08p ps=8.52u w=8u l=0.28u
X351 XRX.XCAP.E_SET_TAIL.t3 E_CAPTURE_CLK.t12 VSS.t48 VSS.t47 nfet_03v3 ad=2.08p pd=8.52u as=2.08p ps=8.52u w=8u l=0.28u
X352 XRX.XCAP.E_PSET_TAIL.t5 E_CAPTURE_CLKB.t6 VDD.t415 VDD.t414 pfet_03v3 ad=2.08p pd=8.52u as=2.08p ps=8.52u w=8u l=0.28u
X353 VSS.t449 XRX.XFRONT.XFE_O.HB.t18 FE_O_N.t4 VSS.t448 nfet_03v3 ad=2.08p pd=8.52u as=2.08p ps=8.52u w=8u l=0.28u
X354 VDD.t110 O_CAPTURE_CLKB.t11 XRX.XCAP.O_PRST_TAIL.t5 VDD.t109 pfet_03v3 ad=2.08p pd=8.52u as=2.08p ps=8.52u w=8u l=0.28u
X355 XRX.XCAP.O_QBI.t10 XRX.XCAP.ODD_D_BUF.t18 XRX.XCAP.O_PRST_TAIL.t11 VDD.t98 pfet_03v3 ad=2.08p pd=8.52u as=2.08p ps=8.52u w=8u l=0.28u
X356 a_n10800_n19772.t0 TERM_EN2_N.t2 VSS.t380 VSS.t41 nfet_03v3 ad=0.44p pd=2.88u as=0.44p ps=2.88u w=1u l=0.28u
X357 a_2148_41600.t7 PI_CLK_N.t6 a_2548_44200.t4 VSS.t174 nfet_03v3 ad=2.08p pd=8.52u as=3.52p ps=16.88u w=8u l=0.28u
X358 VDD.t4 XRX.XFRONT.XFE_E.XP.t51 XRX.XFRONT.XFE_E.XN.t1 VDD.t3 pfet_03v3 ad=2.08p pd=8.52u as=3.52p ps=16.88u w=8u l=0.28u
X359 VDD.t386 XRX.XFRONT.XFE_O.XN.t51 XRX.XFRONT.XFE_O.XP.t30 VDD.t385 pfet_03v3 ad=2.08p pd=8.52u as=3.52p ps=16.88u w=8u l=0.28u
X360 XRX.XFRONT.XFE_E.XN.t3 XRX.XFRONT.XFE_E.XP.t38 XRX.XFRONT.XFE_E.NIN.t1 VSS.t38 nfet_03v3 ad=2.08p pd=8.52u as=2.08p ps=8.52u w=8u l=0.28u
X361 XRX.XCAP.E_QBI.t3 XRX.XCAP.EVEN_D_BUF.t16 XRX.XCAP.E_PRST_TAIL.t1 VDD.t58 pfet_03v3 ad=3.52p pd=16.88u as=2.08p ps=8.52u w=8u l=0.28u
X362 VDD.t270 O_SENSE_CLK.t30 XRX.XFRONT.XFE_O.NIP.t8 VDD.t269 pfet_03v3 ad=2.08p pd=8.52u as=3.52p ps=16.88u w=8u l=0.28u
X363 XRX.XFRONT.XFE_E.HB.t12 XRX.XFRONT.XFE_E.DN.t8 VSS.t260 VSS.t259 nfet_03v3 ad=2.08p pd=8.52u as=2.08p ps=8.52u w=8u l=0.28u
X364 XRX.XFRONT.XFE_E.NIN.t6 SAMP_E_P.t11 XRX.XFRONT.XFE_E.NTAIL.t10 VSS.t81 nfet_03v3 ad=2.08p pd=8.52u as=2.08p ps=8.52u w=8u l=0.28u
X365 VDD.t26 XRX.XCAP.E_QBBUF.t8 EVEN_Q.t0 VDD.t25 pfet_03v3 ad=2.08p pd=8.52u as=2.08p ps=8.52u w=8u l=0.28u
X366 VSS.t210 O_CAPTURE_CLK.t9 XRX.XCAP.O_SET_TAIL.t9 VSS.t209 nfet_03v3 ad=2.08p pd=8.52u as=2.08p ps=8.52u w=8u l=0.28u
X367 XRX.XFRONT.XFE_O.NIN.t15 O_SENSE_CLK.t15 VDD.t312 VDD.t311 pfet_03v3 ad=3.52p pd=16.88u as=2.08p ps=8.52u w=8u l=0.28u
X368 XRX.XFRONT.XFE_O.DP.t4 XRX.XFRONT.XFE_O.XP.t48 VDD.t489 VDD.t488 pfet_03v3 ad=2.08p pd=8.52u as=2.08p ps=8.52u w=8u l=0.28u
X369 XRX.XFRONT.XFE_E.NIP.t10 XRX.XFRONT.XFE_E.XN.t37 XRX.XFRONT.XFE_E.XP.t8 VSS.t76 nfet_03v3 ad=2.08p pd=8.52u as=2.08p ps=8.52u w=8u l=0.28u
X370 XRX.XCAP.E_PRST_TAIL.t7 E_CAPTURE_CLKB.t10 VDD.t421 VDD.t411 pfet_03v3 ad=2.08p pd=8.52u as=2.08p ps=8.52u w=8u l=0.28u
X371 a_n6400_n16252.t4 a_n10800_n16172.t2 a_n7300_n16300.t4 VSS.t450 nfet_03v3 ad=2.6p pd=10.52u as=4.4p ps=20.88u w=10u l=0.28u
X372 VSS.t371 O_SENSE_CLK.t2 XRX.XFRONT.XFE_O.NTAIL.t2 VSS.t370 nfet_03v3 ad=2.6p pd=10.52u as=2.6p ps=10.52u w=10u l=0.28u
X373 XRX.XFRONT.XFE_E.NTAIL.t40 E_SENSE_BOOST.t4 VSS.t322 VSS.t321 nfet_03v3 ad=2.6p pd=10.52u as=2.6p ps=10.52u w=10u l=0.28u
X374 XRX.XFRONT.XFE_O.NTAIL.t44 O_SENSE_BOOST.t0 VSS.t581 VSS.t580 nfet_03v3 ad=4.4p pd=20.88u as=2.6p ps=10.52u w=10u l=0.28u
X375 XRX.XCAP.EVEN_DB_BUF.t3 FE_E_P.t7 VSS.t152 VSS.t151 nfet_03v3 ad=3.52p pd=16.88u as=2.08p ps=8.52u w=8u l=0.28u
X376 VDD.t430 XRX.XFRONT.XFE_E.XP.t53 XRX.XFRONT.XFE_E.HB.t16 VDD.t429 pfet_03v3 ad=2.08p pd=8.52u as=2.08p ps=8.52u w=8u l=0.28u
X377 VDD.t268 XRX.XFRONT.XFE_E.XN.t49 XRX.XFRONT.XFE_E.DN.t1 VDD.t267 pfet_03v3 ad=2.08p pd=8.52u as=3.52p ps=16.88u w=8u l=0.28u
X378 VDD.t360 FE_E_N.t18 XRX.XCAP.EVEN_D_BUF.t4 VDD.t359 pfet_03v3 ad=2.08p pd=8.52u as=3.52p ps=16.88u w=8u l=0.28u
X379 XRX.XCAP.EVEN_D_BUF.t11 FE_E_N.t11 VDD.t370 VDD.t369 pfet_03v3 ad=3.52p pd=16.88u as=2.08p ps=8.52u w=8u l=0.28u
X380 XRX.XCAP.O_RST_TAIL.t1 XRX.XCAP.ODD_DB_BUF.t13 XRX.XCAP.O_QI.t3 VSS.t33 nfet_03v3 ad=2.08p pd=8.52u as=2.08p ps=8.52u w=8u l=0.28u
X381 XRX.XFRONT.XFE_E.XN.t29 E_SENSE_CLK.t22 XRX.XFRONT.XFE_E.XP.t18 VDD.t206 pfet_03v3 ad=2.08p pd=8.52u as=2.08p ps=8.52u w=8u l=0.28u
X382 XRX.XFRONT.XFE_O.NIP.t2 XRX.XFRONT.XFE_O.XN.t41 XRX.XFRONT.XFE_O.XP.t2 VSS.t161 nfet_03v3 ad=2.08p pd=8.52u as=2.08p ps=8.52u w=8u l=0.28u
X383 VDD.t81 FE_E_P.t12 XRX.XCAP.EVEN_DB_BUF.t10 VDD.t80 pfet_03v3 ad=2.08p pd=8.52u as=2.08p ps=8.52u w=8u l=0.28u
X384 VDD.t64 FE_O_P.t18 XRX.XCAP.ODD_DB_BUF.t4 VDD.t63 pfet_03v3 ad=2.08p pd=8.52u as=3.52p ps=16.88u w=8u l=0.28u
X385 XRX.XCAP.ODD_DB_BUF.t11 FE_O_P.t11 VDD.t78 VDD.t77 pfet_03v3 ad=3.52p pd=16.88u as=2.08p ps=8.52u w=8u l=0.28u
X386 VSS.t603 XRX.XCAP.E_QBUF.t4 EVEN_QB.t6 VSS.t602 nfet_03v3 ad=3.52p pd=16.88u as=2.08p ps=8.52u w=8u l=0.28u
X387 VDD.t181 E_SENSE_CLK.t38 XRX.XFRONT.XFE_E.XN.t17 VDD.t180 pfet_03v3 ad=2.08p pd=8.52u as=2.08p ps=8.52u w=8u l=0.28u
X388 VDD.t235 E_SENSE_CLK.t6 XRX.XFRONT.XFE_E.XP.t30 VDD.t234 pfet_03v3 ad=2.08p pd=8.52u as=2.08p ps=8.52u w=8u l=0.28u
X389 VDD.t256 PI_CLK_N.t0 VSS.t153 ppolyf_u r_width=2u r_length=7.5u
X390 VDD.t106 XRX.XFRONT.XFE_O.XN.t49 XRX.XFRONT.XFE_O.DN.t2 VDD.t105 pfet_03v3 ad=2.08p pd=8.52u as=3.52p ps=16.88u w=8u l=0.28u
X391 VSS.t400 XRX.XFRONT.XFE_E.DN.t11 XRX.XFRONT.XFE_E.HB.t9 VSS.t399 nfet_03v3 ad=2.08p pd=8.52u as=2.08p ps=8.52u w=8u l=0.28u
X392 ODD_Q.t5 XRX.XCAP.O_QBBUF.t9 VDD.t453 VDD.t452 pfet_03v3 ad=2.08p pd=8.52u as=2.08p ps=8.52u w=8u l=0.28u
X393 RXP.t0 a_n7157_n21700.t0 VSS.t11 ppolyf_u r_width=1u r_length=2.43u
X394 VSS.t565 O_SENSE_BOOST.t9 XRX.XFRONT.XFE_O.NTAIL.t35 VSS.t564 nfet_03v3 ad=2.6p pd=10.52u as=2.6p ps=10.52u w=10u l=0.28u
X395 XRX.XCAP.E_QBUF.t2 XRX.XCAP.E_QBI.t14 VSS.t605 VSS.t604 nfet_03v3 ad=1.76p pd=8.88u as=1.04p ps=4.52u w=4u l=0.28u
X396 XRX.XCAP.E_QBI.t1 XRX.XCAP.EVEN_D_BUF.t12 XRX.XCAP.E_SET_TAIL.t8 VSS.t70 nfet_03v3 ad=3.52p pd=16.88u as=2.08p ps=8.52u w=8u l=0.28u
X397 XRX.XFRONT.XFE_E.XP.t5 XRX.XFRONT.XFE_E.XN.t40 XRX.XFRONT.XFE_E.NIP.t16 VSS.t226 nfet_03v3 ad=2.08p pd=8.52u as=2.08p ps=8.52u w=8u l=0.28u
X398 RXP.t6 RXN.t7 VSS.t511 ppolyf_u r_width=4u r_length=1.23u
X399 XRX.XFRONT.XFE_O.NIP.t13 SAMP_O_P.t13 XRX.XFRONT.XFE_O.NTAIL.t10 VSS.t406 nfet_03v3 ad=2.08p pd=8.52u as=2.08p ps=8.52u w=8u l=0.28u
X400 SAMP_O_N.t3 RX_RESTP.t3 a_10548_44200.t3 VSS.t510 nfet_03v3 ad=2.64p pd=12.88u as=1.56p ps=6.52u w=6u l=0.28u
X401 XRX.XFRONT.XFE_E.DN.t2 XRX.XFRONT.XFE_E.XN.t44 VSS.t582 VSS.t313 nfet_03v3 ad=3.52p pd=16.88u as=2.08p ps=8.52u w=8u l=0.28u
X402 VSS.t330 E_SENSE_BOOST.t7 XRX.XFRONT.XFE_E.NTAIL.t37 VSS.t329 nfet_03v3 ad=2.6p pd=10.52u as=2.6p ps=10.52u w=10u l=0.28u
X403 VSS.t137 FE_O_P.t10 XRX.XCAP.ODD_DB_BUF.t0 VSS.t136 nfet_03v3 ad=2.08p pd=8.52u as=3.52p ps=16.88u w=8u l=0.28u
X404 XRX.XCAP.O_SET_TAIL.t0 XRX.XCAP.ODD_D_BUF.t15 XRX.XCAP.O_QBI.t0 VSS.t0 nfet_03v3 ad=2.08p pd=8.52u as=3.52p ps=16.88u w=8u l=0.28u
X405 ODD_Q.t0 XRX.XCAP.O_QBBUF.t5 VSS.t404 VSS.t403 nfet_03v3 ad=2.08p pd=8.52u as=2.08p ps=8.52u w=8u l=0.28u
X406 VSS.t146 FE_E_P.t10 XRX.XCAP.EVEN_DB_BUF.t0 VSS.t145 nfet_03v3 ad=2.08p pd=8.52u as=3.52p ps=16.88u w=8u l=0.28u
X407 VDD.t96 a_66600_32348.t0 VSS.t153 ppolyf_u r_width=2u r_length=7.5u
X408 XRX.XFRONT.XFE_E.XP.t15 E_SENSE_CLK.t25 XRX.XFRONT.XFE_E.XN.t28 VDD.t203 pfet_03v3 ad=2.08p pd=8.52u as=2.08p ps=8.52u w=8u l=0.28u
X409 XRX.XFRONT.XFE_O.H.t2 XRX.XFRONT.XFE_O.HB.t27 VDD.t344 VDD.t343 pfet_03v3 ad=2.08p pd=8.52u as=2.08p ps=8.52u w=8u l=0.28u
X410 a_n6400_n19852.t4 a_n10800_n19772.t2 a_n7300_n19900.t4 VSS.t423 nfet_03v3 ad=2.6p pd=10.52u as=4.4p ps=20.88u w=10u l=0.28u
X411 XRX.XFRONT.XFE_E.NTAIL.t24 E_SENSE_BOOST.t20 VSS.t310 VSS.t309 nfet_03v3 ad=2.6p pd=10.52u as=2.6p ps=10.52u w=10u l=0.28u
X412 XRX.XFRONT.XFE_E.HB.t4 XRX.XFRONT.XFE_E.H.t25 VDD.t439 VDD.t438 pfet_03v3 ad=3.52p pd=16.88u as=2.08p ps=8.52u w=8u l=0.28u
X413 VSS.t613 PI_BUF_BIAS.t3 a_80148_31500.t4 VSS.t612 nfet_03v3 ad=2.6p pd=10.52u as=4.4p ps=20.88u w=10u l=0.28u
X414 XRX.XCAP.O_PRST_TAIL.t8 O_CAPTURE_CLKB.t8 VDD.t122 VDD.t121 pfet_03v3 ad=3.52p pd=16.88u as=2.08p ps=8.52u w=8u l=0.28u
X415 VSS.t200 O_CAPTURE_CLK.t7 XRX.XCAP.O_RST_TAIL.t4 VSS.t199 nfet_03v3 ad=2.08p pd=8.52u as=3.52p ps=16.88u w=8u l=0.28u
X416 a_65148_29400.t1 CLK_REST_BIAS.t2 VSS.t294 VSS.t285 nfet_03v3 ad=3.12p pd=12.52u as=3.12p ps=12.52u w=12u l=0.28u
X417 VDD.t112 O_CAPTURE_CLKB.t15 XRX.XCAP.O_PRST_TAIL.t1 VDD.t111 pfet_03v3 ad=2.08p pd=8.52u as=3.52p ps=16.88u w=8u l=0.28u
X418 XRX.XFRONT.XFE_O.DN.t5 XRX.XFRONT.XFE_O.XN.t46 VDD.t400 VDD.t399 pfet_03v3 ad=3.52p pd=16.88u as=2.08p ps=8.52u w=8u l=0.28u
X419 VDD.t290 O_SENSE_CLK.t36 XRX.XFRONT.XFE_O.XP.t12 VDD.t289 pfet_03v3 ad=2.08p pd=8.52u as=2.08p ps=8.52u w=8u l=0.28u
X420 XRX.XCAP.O_QBI.t3 XRX.XCAP.O_QI.t12 VSS.t241 VSS.t102 nfet_03v3 ad=3.52p pd=16.88u as=2.08p ps=8.52u w=8u l=0.28u
X421 XRX.XFRONT.XFE_O.NTAIL.t38 O_SENSE_BOOST.t6 VSS.t569 VSS.t457 nfet_03v3 ad=2.6p pd=10.52u as=2.6p ps=10.52u w=10u l=0.28u
X422 VSS.t359 XRX.XFRONT.XFE_O.DP.t11 XRX.XFRONT.XFE_O.H.t7 VSS.t358 nfet_03v3 ad=2.08p pd=8.52u as=2.08p ps=8.52u w=8u l=0.28u
X423 a_n7157_n23500.t3 a_n10800_n23372.t3 a_n6400_n23452.t4 VSS.t387 nfet_03v3 ad=4.4p pd=20.88u as=2.6p ps=10.52u w=10u l=0.28u
X424 PI_CLK_P.t2 a_65000_32348.t3 a_65148_38800.t7 VSS.t347 nfet_03v3 ad=4.4p pd=20.88u as=2.6p ps=10.52u w=10u l=0.28u
X425 XRX.XFRONT.XFE_O.XN.t20 O_SENSE_CLK.t20 XRX.XFRONT.XFE_O.XP.t19 VDD.t303 pfet_03v3 ad=2.08p pd=8.52u as=2.08p ps=8.52u w=8u l=0.28u
X426 a_n10800_n21572.t0 TERM_EN1_N.t2 VSS.t42 VSS.t41 nfet_03v3 ad=0.44p pd=2.88u as=0.44p ps=2.88u w=1u l=0.28u
X427 VSS.t531 RX_BIAS.t5 a_n5052_n1000.t8 VSS.t517 nfet_03v3 ad=4.4p pd=20.88u as=2.6p ps=10.52u w=10u l=0.28u
X428 XRX.XFRONT.XFE_O.NIN.t5 XRX.XFRONT.XFE_O.XP.t33 XRX.XFRONT.XFE_O.XN.t12 VSS.t271 nfet_03v3 ad=2.08p pd=8.52u as=2.08p ps=8.52u w=8u l=0.28u
X429 XRX.XCAP.EVEN_D_BUF.t1 FE_E_N.t9 VSS.t421 VSS.t364 nfet_03v3 ad=2.08p pd=8.52u as=2.08p ps=8.52u w=8u l=0.28u
X430 VDD.t185 E_SENSE_CLK.t32 XRX.XFRONT.XFE_E.XN.t23 VDD.t184 pfet_03v3 ad=2.08p pd=8.52u as=2.08p ps=8.52u w=8u l=0.28u
X431 a_n7300_n12700.t0 TERM_EN6_N.t1 a_n6400_n12652.t0 VDD.t29 pfet_03v3 ad=4.4p pd=20.88u as=2.6p ps=10.52u w=10u l=0.28u
X432 VDD.t52 XRX.XFRONT.XFE_E.XN.t55 XRX.XFRONT.XFE_E.XP.t0 VDD.t51 pfet_03v3 ad=2.08p pd=8.52u as=3.52p ps=16.88u w=8u l=0.28u
X433 XRX.XFRONT.XFE_E.NIN.t19 E_SENSE_CLK.t29 VDD.t199 VDD.t198 pfet_03v3 ad=2.08p pd=8.52u as=2.08p ps=8.52u w=8u l=0.28u
X434 a_n5052_n1000.t1 RXN.t9 a_n3600_5641.t4 VSS.t376 nfet_03v3 ad=2.6p pd=10.52u as=4.4p ps=20.88u w=10u l=0.28u
X435 VDD.t333 a_n1000_22678.t0 VSS.t242 ppolyf_u r_width=2u r_length=4.2u
X436 XRX.XFRONT.XFE_E.NTAIL.t13 SAMP_E_P.t8 XRX.XFRONT.XFE_E.NIN.t9 VSS.t84 nfet_03v3 ad=2.08p pd=8.52u as=2.08p ps=8.52u w=8u l=0.28u
X437 VDD.t358 FE_E_N.t14 XRX.XCAP.EVEN_D_BUF.t8 VDD.t357 pfet_03v3 ad=2.08p pd=8.52u as=2.08p ps=8.52u w=8u l=0.28u
X438 XRX.XCAP.E_QI.t10 XRX.XCAP.E_QBI.t12 VSS.t395 VSS.t55 nfet_03v3 ad=3.52p pd=16.88u as=2.08p ps=8.52u w=8u l=0.28u
X439 a_65000_32348.t1 PI_RAW_P.t3 a_65148_29400.t4 VSS.t347 nfet_03v3 ad=4.4p pd=20.88u as=2.6p ps=10.52u w=10u l=0.28u
X440 XRX.XCAP.EVEN_DB_BUF.t7 FE_E_P.t15 VDD.t89 VDD.t88 pfet_03v3 ad=2.08p pd=8.52u as=2.08p ps=8.52u w=8u l=0.28u
X441 a_65148_38800.t1 CLK_REST_BIAS.t6 VSS.t286 VSS.t285 nfet_03v3 ad=3.12p pd=12.52u as=3.12p ps=12.52u w=12u l=0.28u
X442 XRX.XFRONT.XFE_O.XP.t15 O_SENSE_CLK.t33 VDD.t276 VDD.t275 pfet_03v3 ad=2.08p pd=8.52u as=2.08p ps=8.52u w=8u l=0.28u
X443 XRX.XFRONT.XFE_E.DN.t4 XRX.XFRONT.XFE_E.XN.t46 VDD.t447 VDD.t446 pfet_03v3 ad=3.52p pd=16.88u as=2.08p ps=8.52u w=8u l=0.28u
X444 XRX.XFRONT.XFE_E.DP.t4 XRX.XFRONT.XFE_E.XP.t46 VDD.t473 VDD.t472 pfet_03v3 ad=3.52p pd=16.88u as=2.08p ps=8.52u w=8u l=0.28u
X445 ODD_Q.t3 XRX.XCAP.O_QBBUF.t7 VDD.t402 VDD.t401 pfet_03v3 ad=3.52p pd=16.88u as=2.08p ps=8.52u w=8u l=0.28u
X446 XRX.XFRONT.XFE_E.XP.t21 E_SENSE_CLK.t19 XRX.XFRONT.XFE_E.XN.t27 VDD.t209 pfet_03v3 ad=3.52p pd=16.88u as=2.08p ps=8.52u w=8u l=0.28u
X447 XRX.XCAP.O_PSET_TAIL.t2 XRX.XCAP.ODD_DB_BUF.t17 XRX.XCAP.O_QI.t8 VDD.t97 pfet_03v3 ad=2.08p pd=8.52u as=2.08p ps=8.52u w=8u l=0.28u
X448 XRX.XCAP.O_PSET_TAIL.t9 O_CAPTURE_CLKB.t2 VDD.t128 VDD.t117 pfet_03v3 ad=2.08p pd=8.52u as=2.08p ps=8.52u w=8u l=0.28u
X449 XRX.XFRONT.XFE_E.XN.t20 E_SENSE_CLK.t35 VDD.t187 VDD.t186 pfet_03v3 ad=2.08p pd=8.52u as=2.08p ps=8.52u w=8u l=0.28u
X450 a_74148_31500.t0 PHASE_B_N.t1 a_75604_31500.t2 VSS.t105 nfet_03v3 ad=1.3p pd=5.52u as=2.2p ps=10.88u w=5u l=0.28u
X451 VDD.t170 RX_RESTP.t0 VSS.t242 ppolyf_u r_width=2u r_length=4.2u
X452 XRX.XCAP.E_PSET_TAIL.t3 XRX.XCAP.EVEN_DB_BUF.t19 XRX.XCAP.E_QI.t0 VDD.t100 pfet_03v3 ad=2.08p pd=8.52u as=3.52p ps=16.88u w=8u l=0.28u
X453 VDD.t36 FE_O_N.t16 XRX.XCAP.ODD_D_BUF.t6 VDD.t35 pfet_03v3 ad=2.08p pd=8.52u as=2.08p ps=8.52u w=8u l=0.28u
X454 XRX.XFRONT.XFE_O.NTAIL.t32 O_SENSE_BOOST.t12 VSS.t561 VSS.t560 nfet_03v3 ad=2.6p pd=10.52u as=2.6p ps=10.52u w=10u l=0.28u
X455 XRX.XFRONT.XFE_E.H.t16 XRX.XFRONT.XFE_E.HB.t17 VSS.t434 VSS.t433 nfet_03v3 ad=3.52p pd=16.88u as=3.52p ps=16.88u w=8u l=0.28u
X456 XRX.XCAP.E_SET_TAIL.t9 XRX.XCAP.EVEN_D_BUF.t15 XRX.XCAP.E_QBI.t2 VSS.t66 nfet_03v3 ad=2.08p pd=8.52u as=3.52p ps=16.88u w=8u l=0.28u
X457 a_12148_44200.t1 PI_CLK_P.t3 a_11748_41600.t4 VSS.t130 nfet_03v3 ad=3.52p pd=16.88u as=2.08p ps=8.52u w=8u l=0.28u
X458 XRX.XFRONT.XFE_E.NTAIL.t16 E_SENSE_CLK.t4 VSS.t275 VSS.t274 nfet_03v3 ad=2.6p pd=10.52u as=4.4p ps=20.88u w=10u l=0.28u
X459 XRX.XFRONT.XFE_O.XN.t23 O_SENSE_CLK.t13 VDD.t316 VDD.t315 pfet_03v3 ad=2.08p pd=8.52u as=2.08p ps=8.52u w=8u l=0.28u
X460 VDD.t372 XRX.XFRONT.XFE_O.HB.t22 FE_O_N.t2 VDD.t371 pfet_03v3 ad=3.52p pd=16.88u as=2.08p ps=8.52u w=8u l=0.28u
X461 a_n6400_n14452.t2 RXN.t4 VSS.t345 ppolyf_u r_width=1u r_length=1u
X462 XRX.XFRONT.XFE_O.XN.t1 XRX.XFRONT.XFE_O.XP.t54 VDD.t242 VDD.t241 pfet_03v3 ad=3.52p pd=16.88u as=2.08p ps=8.52u w=8u l=0.28u
X463 VDD.t296 O_SENSE_CLK.t28 XRX.XFRONT.XFE_O.NIP.t10 VDD.t295 pfet_03v3 ad=2.08p pd=8.52u as=2.08p ps=8.52u w=8u l=0.28u
X464 VSS.t196 XRX.XFRONT.XFE_E.H.t18 FE_E_N.t4 VSS.t195 nfet_03v3 ad=2.08p pd=8.52u as=2.08p ps=8.52u w=8u l=0.28u
X465 VDD.t24 XRX.XFRONT.XFE_E.XP.t49 XRX.XFRONT.XFE_E.DP.t1 VDD.t23 pfet_03v3 ad=2.08p pd=8.52u as=3.52p ps=16.88u w=8u l=0.28u
X466 VSS.t50 E_CAPTURE_CLK.t7 XRX.XCAP.E_RST_TAIL.t1 VSS.t49 nfet_03v3 ad=2.08p pd=8.52u as=3.52p ps=16.88u w=8u l=0.28u
X467 a_n6400_n21652.t2 a_n10800_n21572.t2 a_n7157_n21700.t3 VSS.t173 nfet_03v3 ad=2.6p pd=10.52u as=4.4p ps=20.88u w=10u l=0.28u
X468 XRX.XFRONT.XFE_O.NTAIL.t20 SAMP_O_N.t10 XRX.XFRONT.XFE_O.NIN.t20 VSS.t498 nfet_03v3 ad=2.08p pd=8.52u as=2.08p ps=8.52u w=8u l=0.28u
X469 VDD.t338 a_n6572_3500.t5 VSS.t191 ppolyf_u r_width=2u r_length=4.57u
X470 VSS.t609 XRX.XCAP.E_QBBUF.t4 EVEN_Q.t6 VSS.t608 nfet_03v3 ad=3.52p pd=16.88u as=2.08p ps=8.52u w=8u l=0.28u
X471 XRX.XCAP.E_QBI.t5 XRX.XCAP.E_QI.t12 VSS.t491 VSS.t68 nfet_03v3 ad=3.52p pd=16.88u as=2.08p ps=8.52u w=8u l=0.28u
X472 VSS.t21 SAMP_BIAS.t5 a_2148_41600.t2 VSS.t20 nfet_03v3 ad=2.6p pd=10.52u as=2.6p ps=10.52u w=10u l=0.28u
X473 XRX.XCAP.E_QI.t7 XRX.XCAP.EVEN_DB_BUF.t12 XRX.XCAP.E_RST_TAIL.t0 VSS.t32 nfet_03v3 ad=3.52p pd=16.88u as=2.08p ps=8.52u w=8u l=0.28u
X474 XRX.XFRONT.XFE_E.H.t13 XRX.XFRONT.XFE_E.HB.t22 VDD.t258 VDD.t257 pfet_03v3 ad=3.52p pd=16.88u as=2.08p ps=8.52u w=8u l=0.28u
X475 VDD.t163 XRX.XFRONT.XFE_E.XP.t55 XRX.XFRONT.XFE_E.HB.t6 VDD.t162 pfet_03v3 ad=2.08p pd=8.52u as=3.52p ps=16.88u w=8u l=0.28u
X476 VDD.t136 XRX.XFRONT.XFE_E.XN.t53 XRX.XFRONT.XFE_E.H.t1 VDD.t135 pfet_03v3 ad=2.08p pd=8.52u as=3.52p ps=16.88u w=8u l=0.28u
X477 VDD.t131 a_5300_5958.t1 VSS.t154 ppolyf_u r_width=1u r_length=1.4u
X478 VSS.t98 REST_BIAS.t1 a_n852_19400.t2 VSS.t92 nfet_03v3 ad=3.12p pd=12.52u as=3.12p ps=12.52u w=12u l=0.28u
X479 VDD.t478 SAMP_E_N.t4 VSS.t627 ppolyf_u r_width=2u r_length=5u
X480 a_72404_31500.t1 PHASE_A_P.t0 a_72548_31500.t1 VSS.t29 nfet_03v3 ad=2.2p pd=10.88u as=1.3p ps=5.52u w=5u l=0.28u
X481 XRX.XFRONT.XFE_O.XP.t23 O_SENSE_CLK.t23 XRX.XFRONT.XFE_O.XN.t17 VDD.t300 pfet_03v3 ad=2.08p pd=8.52u as=2.08p ps=8.52u w=8u l=0.28u
X482 XRX.XFRONT.XFE_E.DP.t2 XRX.XFRONT.XFE_E.XP.t44 VSS.t170 VSS.t169 nfet_03v3 ad=3.52p pd=16.88u as=2.08p ps=8.52u w=8u l=0.28u
X483 ODD_QB.t1 XRX.XCAP.O_QBUF.t9 VDD.t404 VDD.t403 pfet_03v3 ad=2.08p pd=8.52u as=2.08p ps=8.52u w=8u l=0.28u
X484 XRX.XFRONT.XFE_E.NIN.t14 XRX.XFRONT.XFE_E.XP.t43 XRX.XFRONT.XFE_E.XN.t8 VSS.t168 nfet_03v3 ad=2.08p pd=8.52u as=3.52p ps=16.88u w=8u l=0.28u
X485 VDD.t240 XRX.XFRONT.XFE_O.XP.t53 XRX.XFRONT.XFE_O.HB.t1 VDD.t239 pfet_03v3 ad=2.08p pd=8.52u as=3.52p ps=16.88u w=8u l=0.28u
X486 VSS.t192 XRX.XFRONT.XFE_E.DP.t7 XRX.XFRONT.XFE_E.H.t8 VSS.t191 nfet_03v3 ad=2.08p pd=8.52u as=2.08p ps=8.52u w=8u l=0.28u
X487 a_n852_28800.t5 a_n1000_22678.t4 RX_RESTP.t1 VSS.t378 nfet_03v3 ad=2.6p pd=10.52u as=4.4p ps=20.88u w=10u l=0.28u
X488 XRX.XFRONT.XFE_E.XP.t3 XRX.XFRONT.XFE_E.XN.t42 XRX.XFRONT.XFE_E.NIP.t22 VSS.t485 nfet_03v3 ad=2.08p pd=8.52u as=2.08p ps=8.52u w=8u l=0.28u
X489 XRX.XCAP.E_PSET_TAIL.t7 E_CAPTURE_CLKB.t4 VDD.t413 VDD.t263 pfet_03v3 ad=2.08p pd=8.52u as=2.08p ps=8.52u w=8u l=0.28u
X490 a_2548_44200.t0 SAMP_E_N.t6 SAMP_E_P.t0 VSS.t9 nfet_03v3 ad=1.56p pd=6.52u as=2.64p ps=12.88u w=6u l=0.28u
X491 XRX.XFRONT.XFE_O.NIN.t23 SAMP_O_N.t7 XRX.XFRONT.XFE_O.NTAIL.t15 VSS.t501 nfet_03v3 ad=3.52p pd=16.88u as=2.08p ps=8.52u w=8u l=0.28u
X492 VDD.t451 XRX.XCAP.E_QBUF.t10 EVEN_QB.t5 VDD.t450 pfet_03v3 ad=2.08p pd=8.52u as=3.52p ps=16.88u w=8u l=0.28u
X493 VSS.t332 E_SENSE_BOOST.t9 XRX.XFRONT.XFE_E.NTAIL.t35 VSS.t331 nfet_03v3 ad=2.6p pd=10.52u as=2.6p ps=10.52u w=10u l=0.28u
X494 VSS.t141 FE_O_P.t8 XRX.XCAP.ODD_DB_BUF.t2 VSS.t140 nfet_03v3 ad=2.08p pd=8.52u as=2.08p ps=8.52u w=8u l=0.28u
X495 a_n7300_n16300.t0 TERM_EN4_N.t1 a_n6400_n16252.t1 VDD.t19 pfet_03v3 ad=4.4p pd=20.88u as=2.6p ps=10.52u w=10u l=0.28u
X496 XRX.XCAP.O_SET_TAIL.t1 XRX.XCAP.ODD_D_BUF.t13 XRX.XCAP.O_QBI.t6 VSS.t102 nfet_03v3 ad=2.08p pd=8.52u as=2.08p ps=8.52u w=8u l=0.28u
X497 VDD.t255 XRX.XFRONT.XFE_E.HB.t25 XRX.XFRONT.XFE_E.H.t12 VDD.t254 pfet_03v3 ad=2.08p pd=8.52u as=3.52p ps=16.88u w=8u l=0.28u
X498 XRX.XFRONT.XFE_O.NIP.t17 SAMP_O_P.t9 XRX.XFRONT.XFE_O.NTAIL.t6 VSS.t410 nfet_03v3 ad=2.08p pd=8.52u as=2.08p ps=8.52u w=8u l=0.28u
X499 VSS.t438 XRX.XFRONT.XFE_E.HB.t19 FE_E_P.t4 VSS.t437 nfet_03v3 ad=2.08p pd=8.52u as=2.08p ps=8.52u w=8u l=0.28u
X500 VSS.t93 REST_BIAS.t5 a_n852_28800.t2 VSS.t92 nfet_03v3 ad=3.12p pd=12.52u as=3.12p ps=12.52u w=12u l=0.28u
X501 XRX.XFRONT.XFE_O.XP.t5 XRX.XFRONT.XFE_O.XN.t36 XRX.XFRONT.XFE_O.NIP.t5 VSS.t164 nfet_03v3 ad=2.08p pd=8.52u as=2.08p ps=8.52u w=8u l=0.28u
X502 a_10548_44200.t4 RX_RESTN.t4 SAMP_O_P.t4 VSS.t620 nfet_03v3 ad=1.56p pd=6.52u as=2.64p ps=12.88u w=6u l=0.28u
X503 a_n852_19400.t7 RX_RAWP.t5 a_n1000_22678.t1 VSS.t378 nfet_03v3 ad=2.6p pd=10.52u as=4.4p ps=20.88u w=10u l=0.28u
X504 VSS.t615 PI_BUF_BIAS.t1 a_80148_31500.t6 VSS.t614 nfet_03v3 ad=2.6p pd=10.52u as=2.6p ps=10.52u w=10u l=0.28u
X505 XRX.XCAP.ODD_D_BUF.t9 FE_O_N.t13 VDD.t42 VDD.t41 pfet_03v3 ad=2.08p pd=8.52u as=2.08p ps=8.52u w=8u l=0.28u
X506 XRX.XFRONT.XFE_E.XP.t25 E_SENSE_CLK.t11 VDD.t225 VDD.t224 pfet_03v3 ad=2.08p pd=8.52u as=2.08p ps=8.52u w=8u l=0.28u
X507 VSS.t118 FE_O_N.t8 XRX.XCAP.ODD_D_BUF.t2 VSS.t117 nfet_03v3 ad=2.08p pd=8.52u as=2.08p ps=8.52u w=8u l=0.28u
X508 XRX.XFRONT.XFE_O.H.t16 XRX.XFRONT.XFE_O.XN.t52 VDD.t388 VDD.t387 pfet_03v3 ad=3.52p pd=16.88u as=2.08p ps=8.52u w=8u l=0.28u
X509 XRX.XFRONT.XFE_O.HB.t14 XRX.XFRONT.XFE_O.XP.t50 VDD.t481 VDD.t480 pfet_03v3 ad=3.52p pd=16.88u as=2.08p ps=8.52u w=8u l=0.28u
X510 a_72548_31500.t7 PI_CTRL_A.t0 VSS.t515 VSS.t233 nfet_03v3 ad=2.2p pd=10.88u as=1.3p ps=5.52u w=5u l=0.28u
X511 a_948_44200.t1 PI_CLK_P.t5 a_2148_41600.t5 VSS.t128 nfet_03v3 ad=3.52p pd=16.88u as=2.08p ps=8.52u w=8u l=0.28u
X512 XRX.XFRONT.XFE_E.H.t5 XRX.XFRONT.XFE_E.DP.t10 VSS.t478 VSS.t477 nfet_03v3 ad=2.08p pd=8.52u as=2.08p ps=8.52u w=8u l=0.28u
X513 XRX.XCAP.E_PRST_TAIL.t3 E_CAPTURE_CLKB.t14 VDD.t418 VDD.t414 pfet_03v3 ad=2.08p pd=8.52u as=2.08p ps=8.52u w=8u l=0.28u
X514 PI_RAW_N.t1 a_75604_31500.t5 a_80148_31500.t1 VSS.t121 nfet_03v3 ad=2.2p pd=10.88u as=1.3p ps=5.52u w=5u l=0.28u
X515 VSS.t56 E_CAPTURE_CLK.t11 XRX.XCAP.E_SET_TAIL.t4 VSS.t55 nfet_03v3 ad=2.08p pd=8.52u as=2.08p ps=8.52u w=8u l=0.28u
X516 VDD.t398 XRX.XFRONT.XFE_E.HB.t27 FE_E_P.t6 VDD.t397 pfet_03v3 ad=2.08p pd=8.52u as=2.08p ps=8.52u w=8u l=0.28u
X517 a_n10800_n14372.t1 TERM_EN5_N.t3 VDD.t14 VDD.t13 pfet_03v3 ad=0.88p pd=4.88u as=0.88p ps=4.88u w=2u l=0.28u
X518 FE_O_N.t0 XRX.XFRONT.XFE_O.HB.t19 VSS.t428 VSS.t427 nfet_03v3 ad=2.08p pd=8.52u as=2.08p ps=8.52u w=8u l=0.28u
X519 VSS.t281 E_SENSE_CLK.t1 XRX.XFRONT.XFE_E.NTAIL.t19 VSS.t280 nfet_03v3 ad=2.6p pd=10.52u as=2.6p ps=10.52u w=10u l=0.28u
X520 XRX.XFRONT.XFE_E.NTAIL.t32 E_SENSE_BOOST.t12 VSS.t326 VSS.t325 nfet_03v3 ad=2.6p pd=10.52u as=2.6p ps=10.52u w=10u l=0.28u
X521 XRX.XFRONT.XFE_E.XN.t0 XRX.XFRONT.XFE_E.XP.t50 VDD.t2 VDD.t1 pfet_03v3 ad=3.52p pd=16.88u as=2.08p ps=8.52u w=8u l=0.28u
X522 VSS.t530 RX_BIAS.t7 a_n5052_n1000.t6 VSS.t520 nfet_03v3 ad=2.6p pd=10.52u as=2.6p ps=10.52u w=10u l=0.28u
X523 XRX.XCAP.ODD_DB_BUF.t7 FE_O_P.t15 VDD.t70 VDD.t69 pfet_03v3 ad=2.08p pd=8.52u as=2.08p ps=8.52u w=8u l=0.28u
X524 XRX.XFRONT.XFE_E.NIN.t0 XRX.XFRONT.XFE_E.XP.t37 XRX.XFRONT.XFE_E.XN.t2 VSS.t37 nfet_03v3 ad=2.08p pd=8.52u as=2.08p ps=8.52u w=8u l=0.28u
X525 XRX.XCAP.O_QI.t10 XRX.XCAP.O_QBI.t16 VDD.t158 VDD.t97 pfet_03v3 ad=3.52p pd=16.88u as=2.08p ps=8.52u w=8u l=0.28u
X526 a_n7300_n19900.t2 TERM_EN2_N.t1 a_n6400_n19852.t2 VDD.t336 pfet_03v3 ad=4.4p pd=20.88u as=2.6p ps=10.52u w=10u l=0.28u
X527 XRX.XFRONT.XFE_E.XP.t9 XRX.XFRONT.XFE_E.XN.t36 XRX.XFRONT.XFE_E.NIP.t9 VSS.t75 nfet_03v3 ad=2.08p pd=8.52u as=2.08p ps=8.52u w=8u l=0.28u
X528 VDD.t306 O_SENSE_CLK.t16 XRX.XFRONT.XFE_O.NIN.t14 VDD.t305 pfet_03v3 ad=2.08p pd=8.52u as=2.08p ps=8.52u w=8u l=0.28u
X529 a_n6400_n18052.t0 RXN.t5 VSS.t422 ppolyf_u r_width=1u r_length=1u
X530 XRX.XFRONT.XFE_O.NIN.t17 SAMP_O_N.t13 XRX.XFRONT.XFE_O.NTAIL.t17 VSS.t495 nfet_03v3 ad=2.08p pd=8.52u as=2.08p ps=8.52u w=8u l=0.28u
X531 XRX.XCAP.O_RST_TAIL.t9 O_CAPTURE_CLK.t2 VSS.t219 VSS.t218 nfet_03v3 ad=2.08p pd=8.52u as=2.08p ps=8.52u w=8u l=0.28u
X532 VDD.t219 E_SENSE_CLK.t14 XRX.XFRONT.XFE_E.XP.t22 VDD.t218 pfet_03v3 ad=2.08p pd=8.52u as=3.52p ps=16.88u w=8u l=0.28u
X533 a_75604_31500.t1 PHASE_A_N.t0 a_72548_31500.t3 VSS.t101 nfet_03v3 ad=2.2p pd=10.88u as=1.3p ps=5.52u w=5u l=0.28u
X534 VSS.t340 E_SENSE_BOOST.t3 XRX.XFRONT.XFE_E.NTAIL.t41 VSS.t339 nfet_03v3 ad=2.6p pd=10.52u as=2.6p ps=10.52u w=10u l=0.28u
X535 ODD_QB.t6 XRX.XCAP.O_QBUF.t7 VDD.t457 VDD.t456 pfet_03v3 ad=3.52p pd=16.88u as=2.08p ps=8.52u w=8u l=0.28u
X536 XRX.XFRONT.XFE_O.XP.t17 O_SENSE_CLK.t31 VDD.t282 VDD.t281 pfet_03v3 ad=3.52p pd=16.88u as=2.08p ps=8.52u w=8u l=0.28u
X537 XRX.XFRONT.XFE_O.NIN.t1 XRX.XFRONT.XFE_O.XP.t41 XRX.XFRONT.XFE_O.XN.t4 VSS.t245 nfet_03v3 ad=2.08p pd=8.52u as=2.08p ps=8.52u w=8u l=0.28u
X538 VSS.t579 O_SENSE_BOOST.t1 XRX.XFRONT.XFE_O.NTAIL.t43 VSS.t578 nfet_03v3 ad=2.6p pd=10.52u as=2.6p ps=10.52u w=10u l=0.28u
X539 XRX.XFRONT.XFE_O.H.t12 XRX.XFRONT.XFE_O.DP.t6 VSS.t181 VSS.t180 nfet_03v3 ad=3.52p pd=16.88u as=2.08p ps=8.52u w=8u l=0.28u
X540 XRX.XFRONT.XFE_E.NIP.t12 XRX.XFRONT.XFE_E.XN.t33 XRX.XFRONT.XFE_E.XP.t12 VSS.t156 nfet_03v3 ad=2.08p pd=8.52u as=2.08p ps=8.52u w=8u l=0.28u
X541 XRX.XCAP.E_SET_TAIL.t1 E_CAPTURE_CLK.t14 VSS.t52 VSS.t51 nfet_03v3 ad=2.08p pd=8.52u as=2.08p ps=8.52u w=8u l=0.28u
X542 XRX.XFRONT.XFE_E.HB.t15 XRX.XFRONT.XFE_E.XP.t52 VDD.t428 VDD.t427 pfet_03v3 ad=3.52p pd=16.88u as=2.08p ps=8.52u w=8u l=0.28u
X543 XRX.XFRONT.XFE_E.XP.t19 E_SENSE_CLK.t21 XRX.XFRONT.XFE_E.XN.t25 VDD.t207 pfet_03v3 ad=2.08p pd=8.52u as=2.08p ps=8.52u w=8u l=0.28u
X544 XRX.XFRONT.XFE_O.XP.t3 XRX.XFRONT.XFE_O.XN.t42 XRX.XFRONT.XFE_O.NIP.t3 VSS.t162 nfet_03v3 ad=2.08p pd=8.52u as=2.08p ps=8.52u w=8u l=0.28u
X545 XRX.XCAP.O_QI.t4 XRX.XCAP.ODD_DB_BUF.t14 XRX.XCAP.O_RST_TAIL.t2 VSS.t35 nfet_03v3 ad=2.08p pd=8.52u as=2.08p ps=8.52u w=8u l=0.28u
X546 VSS.t597 XRX.XCAP.O_QBUF.t6 ODD_QB.t4 VSS.t596 nfet_03v3 ad=2.08p pd=8.52u as=3.52p ps=16.88u w=8u l=0.28u
X547 VSS.t269 XRX.XFRONT.XFE_O.DN.t13 XRX.XFRONT.XFE_O.HB.t2 VSS.t268 nfet_03v3 ad=2.08p pd=8.52u as=3.52p ps=16.88u w=8u l=0.28u
X548 VSS.t432 XRX.XFRONT.XFE_O.HB.t21 XRX.XFRONT.XFE_O.H.t0 VSS.t431 nfet_03v3 ad=3.52p pd=16.88u as=3.52p ps=16.88u w=8u l=0.28u
X549 EVEN_QB.t4 XRX.XCAP.E_QBUF.t5 VSS.t595 VSS.t594 nfet_03v3 ad=2.08p pd=8.52u as=2.08p ps=8.52u w=8u l=0.28u
X550 VDD.t425 E_CAPTURE_CLKB.t1 XRX.XCAP.E_PSET_TAIL.t10 VDD.t409 pfet_03v3 ad=2.08p pd=8.52u as=2.08p ps=8.52u w=8u l=0.28u
X551 a_n6400_n14452.t0 TERM_EN5_N.t0 a_n7300_n14500.t1 VDD.t16 pfet_03v3 ad=2.6p pd=10.52u as=4.4p ps=20.88u w=10u l=0.28u
X552 RX_RAWP.t2 a_n6572_3500.t6 a_2148_n500.t1 VSS.t376 nfet_03v3 ad=2.2p pd=10.88u as=1.3p ps=5.52u w=5u l=0.28u
X553 EVEN_QB.t0 XRX.XCAP.E_QBUF.t7 VDD.t62 VDD.t61 pfet_03v3 ad=3.52p pd=16.88u as=2.08p ps=8.52u w=8u l=0.28u
X554 XRX.XFRONT.XFE_E.XN.t9 XRX.XFRONT.XFE_E.XP.t40 XRX.XFRONT.XFE_E.NIN.t15 VSS.t188 nfet_03v3 ad=2.08p pd=8.52u as=2.08p ps=8.52u w=8u l=0.28u
X555 XRX.XCAP.E_QI.t5 XRX.XCAP.EVEN_DB_BUF.t14 XRX.XCAP.E_RST_TAIL.t10 VSS.t47 nfet_03v3 ad=2.08p pd=8.52u as=2.08p ps=8.52u w=8u l=0.28u
X556 XRX.XFRONT.XFE_E.NIN.t4 SAMP_E_P.t13 XRX.XFRONT.XFE_E.NTAIL.t14 VSS.t79 nfet_03v3 ad=2.08p pd=8.52u as=2.08p ps=8.52u w=8u l=0.28u
X557 XRX.XCAP.E_SET_TAIL.t10 XRX.XCAP.EVEN_D_BUF.t13 XRX.XCAP.E_QBI.t8 VSS.t68 nfet_03v3 ad=2.08p pd=8.52u as=2.08p ps=8.52u w=8u l=0.28u
X558 VDD.t60 a_600_22678.t2 VSS.t135 ppolyf_u r_width=2u r_length=4.2u
X559 XRX.XFRONT.XFE_E.NIP.t15 XRX.XFRONT.XFE_E.XN.t39 XRX.XFRONT.XFE_E.XP.t6 VSS.t225 nfet_03v3 ad=2.08p pd=8.52u as=2.08p ps=8.52u w=8u l=0.28u
X560 VSS.t607 XRX.XCAP.E_QBI.t15 XRX.XCAP.E_QBUF.t3 VSS.t606 nfet_03v3 ad=1.04p pd=4.52u as=1.76p ps=8.88u w=4u l=0.28u
X561 a_10548_44200.t2 RX_RESTP.t4 SAMP_O_N.t4 VSS.t509 nfet_03v3 ad=1.56p pd=6.52u as=2.64p ps=12.88u w=6u l=0.28u
X562 VSS.t373 O_SENSE_CLK.t0 XRX.XFRONT.XFE_O.NTAIL.t4 VSS.t372 nfet_03v3 ad=4.4p pd=20.88u as=2.6p ps=10.52u w=10u l=0.28u
X563 XRX.XFRONT.XFE_E.NTAIL.t38 E_SENSE_BOOST.t6 VSS.t336 VSS.t335 nfet_03v3 ad=2.6p pd=10.52u as=2.6p ps=10.52u w=10u l=0.28u
X564 RXP.t5 a_n7300_n14500.t2 VSS.t11 ppolyf_u r_width=1u r_length=1u
X565 VSS.t183 XRX.XFRONT.XFE_E.H.t20 FE_E_N.t0 VSS.t182 nfet_03v3 ad=2.08p pd=8.52u as=3.52p ps=16.88u w=8u l=0.28u
X566 XRX.XFRONT.XFE_E.XN.t13 E_SENSE_CLK.t24 XRX.XFRONT.XFE_E.XP.t16 VDD.t204 pfet_03v3 ad=2.08p pd=8.52u as=2.08p ps=8.52u w=8u l=0.28u
X567 VDD.t141 XRX.XFRONT.XFE_E.H.t23 FE_E_N.t2 VDD.t140 pfet_03v3 ad=2.08p pd=8.52u as=2.08p ps=8.52u w=8u l=0.28u
X568 XRX.XFRONT.XFE_O.NIP.t0 XRX.XFRONT.XFE_O.XN.t39 XRX.XFRONT.XFE_O.XP.t0 VSS.t159 nfet_03v3 ad=2.08p pd=8.52u as=2.08p ps=8.52u w=8u l=0.28u
X569 a_74148_31500.t5 PI_CTRL_B.t0 VSS.t234 VSS.t233 nfet_03v3 ad=2.2p pd=10.88u as=1.3p ps=5.52u w=5u l=0.28u
X570 XRX.XFRONT.XFE_O.NTAIL.t24 O_SENSE_BOOST.t20 VSS.t547 VSS.t546 nfet_03v3 ad=2.6p pd=10.52u as=2.6p ps=10.52u w=10u l=0.28u
X571 VDD.t177 E_SENSE_CLK.t40 XRX.XFRONT.XFE_E.XN.t15 VDD.t176 pfet_03v3 ad=2.08p pd=8.52u as=3.52p ps=16.88u w=8u l=0.28u
X572 a_11748_41600.t3 SAMP_BIAS.t0 VSS.t27 VSS.t26 nfet_03v3 ad=4.4p pd=20.88u as=2.6p ps=10.52u w=10u l=0.28u
X573 VSS.t251 XRX.XFRONT.XFE_O.XP.t45 XRX.XFRONT.XFE_O.DP.t1 VSS.t250 nfet_03v3 ad=2.08p pd=8.52u as=3.52p ps=16.88u w=8u l=0.28u
X574 VDD.t364 FE_E_N.t16 XRX.XCAP.EVEN_D_BUF.t6 VDD.t363 pfet_03v3 ad=2.08p pd=8.52u as=2.08p ps=8.52u w=8u l=0.28u
X575 XRX.XCAP.EVEN_DB_BUF.t5 FE_E_P.t17 VDD.t83 VDD.t82 pfet_03v3 ad=2.08p pd=8.52u as=2.08p ps=8.52u w=8u l=0.28u
X576 VDD.t231 E_SENSE_CLK.t8 XRX.XFRONT.XFE_E.XP.t28 VDD.t230 pfet_03v3 ad=2.08p pd=8.52u as=2.08p ps=8.52u w=8u l=0.28u
X577 VSS.t512 PI_CTRL_A.t3 a_72548_31500.t4 VSS.t227 nfet_03v3 ad=1.3p pd=5.52u as=2.2p ps=10.88u w=5u l=0.28u
X578 VDD.t264 XRX.XCAP.E_QI.t17 XRX.XCAP.E_QBI.t6 VDD.t263 pfet_03v3 ad=2.08p pd=8.52u as=3.52p ps=16.88u w=8u l=0.28u
X579 XRX.XCAP.ODD_DB_BUF.t9 FE_O_P.t13 VDD.t74 VDD.t73 pfet_03v3 ad=2.08p pd=8.52u as=2.08p ps=8.52u w=8u l=0.28u
X580 VDD.t378 XRX.XFRONT.XFE_O.XN.t55 XRX.XFRONT.XFE_O.H.t15 VDD.t377 pfet_03v3 ad=2.08p pd=8.52u as=3.52p ps=16.88u w=8u l=0.28u
X581 VDD.t102 XRX.XFRONT.XFE_O.XN.t47 XRX.XFRONT.XFE_O.DN.t0 VDD.t101 pfet_03v3 ad=2.08p pd=8.52u as=2.08p ps=8.52u w=8u l=0.28u
X582 VSS.t426 XRX.XFRONT.XFE_E.DN.t13 XRX.XFRONT.XFE_E.HB.t7 VSS.t425 nfet_03v3 ad=2.08p pd=8.52u as=3.52p ps=16.88u w=8u l=0.28u
X583 VDD.t146 RX_RESTN.t0 VSS.t135 ppolyf_u r_width=2u r_length=4.2u
X584 SAMP_E_N.t0 SAMP_E_P.t5 a_2548_44200.t3 VSS.t87 nfet_03v3 ad=2.64p pd=12.88u as=1.56p ps=6.52u w=6u l=0.28u
X585 VSS.t624 XRX.XCAP.O_QI.t13 XRX.XCAP.O_QBI.t2 VSS.t103 nfet_03v3 ad=2.08p pd=8.52u as=3.52p ps=16.88u w=8u l=0.28u
X586 a_n6572_3500.t4 VTHP.t0 a_n5052_2600.t3 VSS.t381 nfet_03v3 ad=0.88p pd=4.88u as=0.52p ps=2.52u w=2u l=0.28u
X587 VSS.t568 O_SENSE_BOOST.t7 XRX.XFRONT.XFE_O.NTAIL.t37 VSS.t459 nfet_03v3 ad=2.6p pd=10.52u as=2.6p ps=10.52u w=10u l=0.28u
X588 XRX.XFRONT.XFE_O.H.t6 XRX.XFRONT.XFE_O.DP.t12 VSS.t466 VSS.t465 nfet_03v3 ad=2.08p pd=8.52u as=2.08p ps=8.52u w=8u l=0.28u
X589 a_65148_38800.t6 a_65000_32348.t4 PI_CLK_P.t1 VSS.t346 nfet_03v3 ad=2.6p pd=10.52u as=4.4p ps=20.88u w=10u l=0.28u
X590 VDD.t326 O_SENSE_CLK.t8 XRX.XFRONT.XFE_O.XN.t28 VDD.t325 pfet_03v3 ad=2.08p pd=8.52u as=2.08p ps=8.52u w=8u l=0.28u
X591 VSS.t202 O_CAPTURE_CLK.t15 XRX.XCAP.O_SET_TAIL.t3 VSS.t201 nfet_03v3 ad=2.08p pd=8.52u as=3.52p ps=16.88u w=8u l=0.28u
X592 a_2148_n500.t4 RX_BIAS.t3 VSS.t518 VSS.t517 nfet_03v3 ad=2.6p pd=10.52u as=2.6p ps=10.52u w=10u l=0.28u
X593 FE_O_P.t5 XRX.XFRONT.XFE_O.H.t18 VSS.t591 VSS.t590 nfet_03v3 ad=3.52p pd=16.88u as=2.08p ps=8.52u w=8u l=0.28u
X594 XRX.XCAP.O_PSET_TAIL.t5 O_CAPTURE_CLKB.t6 VDD.t124 VDD.t115 pfet_03v3 ad=2.08p pd=8.52u as=2.08p ps=8.52u w=8u l=0.28u
X595 a_n10800_n17972.t1 TERM_EN3_N.t3 VDD.t433 VDD.t432 pfet_03v3 ad=0.88p pd=4.88u as=0.88p ps=4.88u w=2u l=0.28u
X596 SAMP_O_P.t1 SAMP_O_N.t5 a_12148_44200.t5 VSS.t503 nfet_03v3 ad=2.64p pd=12.88u as=1.56p ps=6.52u w=6u l=0.28u
X597 XRX.XCAP.E_RST_TAIL.t6 E_CAPTURE_CLK.t2 VSS.t71 VSS.t70 nfet_03v3 ad=2.08p pd=8.52u as=2.08p ps=8.52u w=8u l=0.28u
X598 XRX.XFRONT.XFE_E.XP.t1 XRX.XFRONT.XFE_E.XN.t54 VDD.t50 VDD.t49 pfet_03v3 ad=3.52p pd=16.88u as=2.08p ps=8.52u w=8u l=0.28u
X599 VDD.t238 a_n1900_5958.t1 VSS.t284 ppolyf_u r_width=1u r_length=1.4u
X600 XRX.XFRONT.XFE_E.NIN.t10 SAMP_E_P.t7 XRX.XFRONT.XFE_E.NTAIL.t9 VSS.t85 nfet_03v3 ad=3.52p pd=16.88u as=2.08p ps=8.52u w=8u l=0.28u
X601 a_n7157_n21700.t1 TERM_EN1_N.t1 a_n6400_n21652.t1 VDD.t11 pfet_03v3 ad=4.4p pd=20.88u as=2.6p ps=10.52u w=10u l=0.28u
X602 a_65148_29400.t5 PI_RAW_P.t4 a_65000_32348.t0 VSS.t346 nfet_03v3 ad=2.6p pd=10.52u as=4.4p ps=20.88u w=10u l=0.28u
X603 VSS.t213 O_CAPTURE_CLK.t5 XRX.XCAP.O_RST_TAIL.t6 VSS.t0 nfet_03v3 ad=2.08p pd=8.52u as=2.08p ps=8.52u w=8u l=0.28u
X604 XRX.XCAP.O_QBUF.t2 XRX.XCAP.O_QBI.t14 VSS.t253 VSS.t252 nfet_03v3 ad=1.76p pd=8.88u as=1.04p ps=4.52u w=4u l=0.28u
X605 VDD.t423 E_CAPTURE_CLKB.t5 XRX.XCAP.E_PSET_TAIL.t6 VDD.t407 pfet_03v3 ad=2.08p pd=8.52u as=2.08p ps=8.52u w=8u l=0.28u
X606 VSS.t363 XRX.XFRONT.XFE_E.HB.t21 FE_E_P.t1 VSS.t362 nfet_03v3 ad=2.08p pd=8.52u as=3.52p ps=16.88u w=8u l=0.28u
X607 XRX.XCAP.O_PRST_TAIL.t10 XRX.XCAP.ODD_D_BUF.t17 XRX.XCAP.O_QBI.t9 VDD.t97 pfet_03v3 ad=2.08p pd=8.52u as=2.08p ps=8.52u w=8u l=0.28u
X608 a_n7300_n12700.t4 a_n10800_n12572.t3 a_n6400_n12652.t4 VSS.t389 nfet_03v3 ad=4.4p pd=20.88u as=2.6p ps=10.52u w=10u l=0.28u
X609 XRX.XFRONT.XFE_O.NTAIL.t40 O_SENSE_BOOST.t4 VSS.t575 VSS.t574 nfet_03v3 ad=2.6p pd=10.52u as=2.6p ps=10.52u w=10u l=0.28u
X610 VSS.t398 XRX.XFRONT.XFE_O.DP.t9 XRX.XFRONT.XFE_O.H.t9 VSS.t397 nfet_03v3 ad=2.08p pd=8.52u as=2.08p ps=8.52u w=8u l=0.28u
X611 XRX.XCAP.O_PRST_TAIL.t6 O_CAPTURE_CLKB.t10 VDD.t118 VDD.t117 pfet_03v3 ad=2.08p pd=8.52u as=2.08p ps=8.52u w=8u l=0.28u
X612 VDD.t189 E_SENSE_CLK.t34 XRX.XFRONT.XFE_E.XN.t21 VDD.t188 pfet_03v3 ad=2.08p pd=8.52u as=2.08p ps=8.52u w=8u l=0.28u
X613 XRX.XCAP.E_PRST_TAIL.t0 XRX.XCAP.EVEN_D_BUF.t19 XRX.XCAP.E_QBI.t0 VDD.t100 pfet_03v3 ad=2.08p pd=8.52u as=3.52p ps=16.88u w=8u l=0.28u
X614 EVEN_Q.t4 XRX.XCAP.E_QBBUF.t9 VDD.t443 VDD.t442 pfet_03v3 ad=2.08p pd=8.52u as=2.08p ps=8.52u w=8u l=0.28u
X615 VDD.t56 a_n6716_3500.t1 VSS.t134 ppolyf_u r_width=1u r_length=1.4u
X616 XRX.XFRONT.XFE_E.NTAIL.t11 SAMP_E_P.t10 XRX.XFRONT.XFE_E.NIN.t7 VSS.t82 nfet_03v3 ad=2.08p pd=8.52u as=2.08p ps=8.52u w=8u l=0.28u
X617 a_n5052_2600.t2 VTHP.t1 a_n6572_3500.t3 VSS.t381 nfet_03v3 ad=0.52p pd=2.52u as=0.88p ps=4.88u w=2u l=0.28u
X618 a_n6400_n18052.t4 TERM_EN3_N.t0 a_n7300_n18100.t4 VDD.t435 pfet_03v3 ad=2.6p pd=10.52u as=4.4p ps=20.88u w=10u l=0.28u
X619 a_11748_41600.t5 PI_CLK_P.t4 a_12148_44200.t0 VSS.t129 nfet_03v3 ad=2.08p pd=8.52u as=3.52p ps=16.88u w=8u l=0.28u
X620 VSS.t277 E_SENSE_CLK.t3 XRX.XFRONT.XFE_E.NTAIL.t17 VSS.t276 nfet_03v3 ad=2.6p pd=10.52u as=2.6p ps=10.52u w=10u l=0.28u
X621 FE_O_N.t5 XRX.XFRONT.XFE_O.HB.t23 VDD.t390 VDD.t389 pfet_03v3 ad=2.08p pd=8.52u as=2.08p ps=8.52u w=8u l=0.28u
X622 VDD.t314 O_SENSE_CLK.t14 XRX.XFRONT.XFE_O.XN.t22 VDD.t313 pfet_03v3 ad=2.08p pd=8.52u as=3.52p ps=16.88u w=8u l=0.28u
X623 XRX.XFRONT.XFE_E.NTAIL.t3 SAMP_E_N.t8 XRX.XFRONT.XFE_E.NIP.t6 VSS.t7 nfet_03v3 ad=2.08p pd=8.52u as=2.08p ps=8.52u w=8u l=0.28u
X624 VDD.t244 XRX.XFRONT.XFE_O.XP.t55 XRX.XFRONT.XFE_O.XN.t0 VDD.t243 pfet_03v3 ad=2.08p pd=8.52u as=3.52p ps=16.88u w=8u l=0.28u
X625 a_5300_5958.t0 RX_BW_EN_N.t0 RX_RAWN.t0 VDD.t8 pfet_03v3 ad=2.2p pd=10.88u as=2.2p ps=10.88u w=5u l=0.28u
X626 XRX.XFRONT.XFE_O.NIP.t9 O_SENSE_CLK.t29 VDD.t272 VDD.t271 pfet_03v3 ad=2.08p pd=8.52u as=2.08p ps=8.52u w=8u l=0.28u
X627 FE_E_N.t3 XRX.XFRONT.XFE_E.H.t17 VSS.t194 VSS.t193 nfet_03v3 ad=3.52p pd=16.88u as=2.08p ps=8.52u w=8u l=0.28u
X628 VDD.t362 FE_E_N.t12 XRX.XCAP.EVEN_D_BUF.t10 VDD.t361 pfet_03v3 ad=2.08p pd=8.52u as=2.08p ps=8.52u w=8u l=0.28u
X629 VSS.t228 PI_CTRL_B.t3 a_74148_31500.t2 VSS.t227 nfet_03v3 ad=1.3p pd=5.52u as=2.2p ps=10.88u w=5u l=0.28u
X630 XRX.XFRONT.XFE_O.NIN.t19 SAMP_O_N.t11 XRX.XFRONT.XFE_O.NTAIL.t19 VSS.t497 nfet_03v3 ad=2.08p pd=8.52u as=2.08p ps=8.52u w=8u l=0.28u
X631 VDD.t132 a_n3600_5641.t1 VSS.t167 ppolyf_u r_width=2u r_length=4.57u
X632 RXP.t4 a_n7300_n18100.t0 VSS.t11 ppolyf_u r_width=1u r_length=1u
X633 VDD.t148 PI_RAW_P.t0 VSS.t187 ppolyf_u r_width=2u r_length=5.25u
X634 VSS.t543 O_SENSE_BOOST.t23 XRX.XFRONT.XFE_O.NTAIL.t21 VSS.t542 nfet_03v3 ad=2.6p pd=10.52u as=4.4p ps=20.88u w=10u l=0.28u
X635 VSS.t492 XRX.XCAP.E_QI.t13 XRX.XCAP.E_QBI.t4 VSS.t62 nfet_03v3 ad=2.08p pd=8.52u as=3.52p ps=16.88u w=8u l=0.28u
X636 XRX.XFRONT.XFE_E.XN.t18 E_SENSE_CLK.t37 VDD.t183 VDD.t182 pfet_03v3 ad=2.08p pd=8.52u as=2.08p ps=8.52u w=8u l=0.28u
X637 VSS.t23 SAMP_BIAS.t3 a_11748_41600.t0 VSS.t22 nfet_03v3 ad=2.6p pd=10.52u as=4.4p ps=20.88u w=10u l=0.28u
X638 a_2148_41600.t1 SAMP_BIAS.t6 VSS.t19 VSS.t18 nfet_03v3 ad=2.6p pd=10.52u as=2.6p ps=10.52u w=10u l=0.28u
X639 XRX.XCAP.O_PSET_TAIL.t0 XRX.XCAP.ODD_DB_BUF.t19 XRX.XCAP.O_QI.t6 VDD.t57 pfet_03v3 ad=2.08p pd=8.52u as=3.52p ps=16.88u w=8u l=0.28u
X640 VDD.t455 XRX.XCAP.O_QBBUF.t8 ODD_Q.t6 VDD.t454 pfet_03v3 ad=2.08p pd=8.52u as=2.08p ps=8.52u w=8u l=0.28u
X641 VSS.t593 XRX.XCAP.O_QBUF.t4 ODD_QB.t2 VSS.t592 nfet_03v3 ad=3.52p pd=16.88u as=2.08p ps=8.52u w=8u l=0.28u
X642 a_72548_31500.t0 PHASE_A_P.t1 a_72404_31500.t0 VSS.t28 nfet_03v3 ad=1.3p pd=5.52u as=2.2p ps=10.88u w=5u l=0.28u
X643 VSS.t300 E_SENSE_BOOST.t17 XRX.XFRONT.XFE_E.NTAIL.t27 VSS.t299 nfet_03v3 ad=2.6p pd=10.52u as=2.6p ps=10.52u w=10u l=0.28u
X644 XRX.XFRONT.XFE_O.XN.t25 O_SENSE_CLK.t11 VDD.t320 VDD.t319 pfet_03v3 ad=2.08p pd=8.52u as=2.08p ps=8.52u w=8u l=0.28u
X645 VSS.t240 XRX.XFRONT.XFE_O.H.t21 FE_O_P.t4 VSS.t239 nfet_03v3 ad=2.08p pd=8.52u as=3.52p ps=16.88u w=8u l=0.28u
X646 XRX.XFRONT.XFE_E.NIP.t3 SAMP_E_N.t11 XRX.XFRONT.XFE_E.NTAIL.t0 VSS.t4 nfet_03v3 ad=2.08p pd=8.52u as=2.08p ps=8.52u w=8u l=0.28u
X647 XRX.XCAP.E_PSET_TAIL.t1 XRX.XCAP.EVEN_DB_BUF.t17 XRX.XCAP.E_QI.t2 VDD.t59 pfet_03v3 ad=2.08p pd=8.52u as=2.08p ps=8.52u w=8u l=0.28u
X648 XRX.XFRONT.XFE_E.XN.t11 XRX.XFRONT.XFE_E.XP.t42 XRX.XFRONT.XFE_E.NIN.t17 VSS.t190 nfet_03v3 ad=2.08p pd=8.52u as=2.08p ps=8.52u w=8u l=0.28u
X649 XRX.XCAP.E_PRST_TAIL.t5 E_CAPTURE_CLKB.t12 VDD.t420 VDD.t263 pfet_03v3 ad=2.08p pd=8.52u as=2.08p ps=8.52u w=8u l=0.28u
X650 XRX.XCAP.ODD_D_BUF.t5 FE_O_N.t17 VDD.t34 VDD.t33 pfet_03v3 ad=2.08p pd=8.52u as=2.08p ps=8.52u w=8u l=0.28u
X651 XRX.XFRONT.XFE_O.XP.t9 O_SENSE_CLK.t39 VDD.t280 VDD.t279 pfet_03v3 ad=2.08p pd=8.52u as=2.08p ps=8.52u w=8u l=0.28u
X652 VSS.t67 E_CAPTURE_CLK.t5 XRX.XCAP.E_RST_TAIL.t3 VSS.t66 nfet_03v3 ad=2.08p pd=8.52u as=2.08p ps=8.52u w=8u l=0.28u
X653 a_n3600_5641.t5 RXN.t8 a_n5052_n1000.t0 VSS.t376 nfet_03v3 ad=4.4p pd=20.88u as=2.6p ps=10.52u w=10u l=0.28u
X654 RX_RESTP.t2 a_n1000_22678.t3 a_n852_28800.t6 VSS.t379 nfet_03v3 ad=4.4p pd=20.88u as=2.6p ps=10.52u w=10u l=0.28u
X655 XRX.XFRONT.XFE_O.NTAIL.t14 SAMP_O_N.t8 XRX.XFRONT.XFE_O.NIN.t22 VSS.t500 nfet_03v3 ad=2.08p pd=8.52u as=2.08p ps=8.52u w=8u l=0.28u
X656 XRX.XFRONT.XFE_O.XN.t9 XRX.XFRONT.XFE_O.XP.t36 XRX.XFRONT.XFE_O.NIN.t8 VSS.t351 nfet_03v3 ad=2.08p pd=8.52u as=2.08p ps=8.52u w=8u l=0.28u
X657 VSS.t462 XRX.XCAP.E_QBBUF.t6 EVEN_Q.t2 VSS.t461 nfet_03v3 ad=2.08p pd=8.52u as=3.52p ps=16.88u w=8u l=0.28u
X658 XRX.XCAP.O_QBI.t7 XRX.XCAP.ODD_D_BUF.t14 XRX.XCAP.O_SET_TAIL.t2 VSS.t103 nfet_03v3 ad=2.08p pd=8.52u as=2.08p ps=8.52u w=8u l=0.28u
X659 VDD.t152 XRX.XFRONT.XFE_O.H.t28 FE_O_P.t1 VDD.t151 pfet_03v3 ad=2.08p pd=8.52u as=3.52p ps=16.88u w=8u l=0.28u
X660 XRX.XFRONT.XFE_O.NTAIL.t5 SAMP_O_P.t10 XRX.XFRONT.XFE_O.NIP.t16 VSS.t409 nfet_03v3 ad=2.08p pd=8.52u as=2.08p ps=8.52u w=8u l=0.28u
X661 FE_E_P.t3 XRX.XFRONT.XFE_E.HB.t18 VSS.t436 VSS.t435 nfet_03v3 ad=3.52p pd=16.88u as=2.08p ps=8.52u w=8u l=0.28u
X662 a_n1000_22678.t2 RX_RAWP.t4 a_n852_19400.t6 VSS.t379 nfet_03v3 ad=4.4p pd=20.88u as=2.6p ps=10.52u w=10u l=0.28u
X663 XRX.XFRONT.XFE_O.HB.t7 XRX.XFRONT.XFE_O.DN.t8 VSS.t265 VSS.t264 nfet_03v3 ad=2.08p pd=8.52u as=2.08p ps=8.52u w=8u l=0.28u
X664 VSS.t420 FE_E_N.t8 XRX.XCAP.EVEN_D_BUF.t2 VSS.t419 nfet_03v3 ad=2.08p pd=8.52u as=2.08p ps=8.52u w=8u l=0.28u
X665 XRX.XFRONT.XFE_E.H.t0 XRX.XFRONT.XFE_E.XN.t52 VDD.t134 VDD.t133 pfet_03v3 ad=2.08p pd=8.52u as=2.08p ps=8.52u w=8u l=0.28u
X666 VDD.t53 SAMP_E_P.t2 VSS.t131 ppolyf_u r_width=2u r_length=5u
X667 XRX.XCAP.ODD_D_BUF.t1 FE_O_N.t9 VSS.t116 VSS.t115 nfet_03v3 ad=2.08p pd=8.52u as=2.08p ps=8.52u w=8u l=0.28u
X668 VDD.t483 XRX.XFRONT.XFE_O.XP.t51 XRX.XFRONT.XFE_O.HB.t15 VDD.t482 pfet_03v3 ad=2.08p pd=8.52u as=2.08p ps=8.52u w=8u l=0.28u
X669 VDD.t79 RX_RAWP.t1 VSS.t144 ppolyf_u r_width=2u r_length=3.43u
X670 a_n7300_n16300.t3 a_n10800_n16172.t3 a_n6400_n16252.t3 VSS.t382 nfet_03v3 ad=4.4p pd=20.88u as=2.6p ps=10.52u w=10u l=0.28u
X671 a_n852_19400.t1 REST_BIAS.t2 VSS.t97 VSS.t90 nfet_03v3 ad=3.12p pd=12.52u as=3.12p ps=12.52u w=12u l=0.28u
X672 VSS.t514 PI_CTRL_A.t1 a_72548_31500.t6 VSS.t231 nfet_03v3 ad=1.3p pd=5.52u as=1.3p ps=5.52u w=5u l=0.28u
X673 VDD.t374 XRX.XFRONT.XFE_O.XN.t53 XRX.XFRONT.XFE_O.H.t13 VDD.t373 pfet_03v3 ad=2.08p pd=8.52u as=2.08p ps=8.52u w=8u l=0.28u
X674 a_n10800_n14372.t0 TERM_EN5_N.t2 VSS.t104 VSS.t41 nfet_03v3 ad=0.44p pd=2.88u as=0.44p ps=2.88u w=1u l=0.28u
X675 a_2148_41600.t4 PI_CLK_P.t6 a_948_44200.t0 VSS.t127 nfet_03v3 ad=2.08p pd=8.52u as=3.52p ps=16.88u w=8u l=0.28u
X676 VSS.t476 XRX.XFRONT.XFE_E.DP.t9 XRX.XFRONT.XFE_E.H.t6 VSS.t475 nfet_03v3 ad=2.08p pd=8.52u as=2.08p ps=8.52u w=8u l=0.28u
X677 a_80148_31500.t0 a_75604_31500.t6 PI_RAW_N.t0 VSS.t108 nfet_03v3 ad=1.3p pd=5.52u as=2.2p ps=10.88u w=5u l=0.28u
X678 VDD.t195 E_SENSE_CLK.t28 XRX.XFRONT.XFE_E.NIN.t20 VDD.t194 pfet_03v3 ad=2.08p pd=8.52u as=2.08p ps=8.52u w=8u l=0.28u
X679 a_2148_n500.t6 RX_BIAS.t1 VSS.t534 VSS.t517 nfet_03v3 ad=2.6p pd=10.52u as=2.6p ps=10.52u w=10u l=0.28u
X680 VSS.t328 E_SENSE_BOOST.t11 XRX.XFRONT.XFE_E.NTAIL.t33 VSS.t327 nfet_03v3 ad=2.6p pd=10.52u as=2.6p ps=10.52u w=10u l=0.28u
X681 XRX.XFRONT.XFE_E.NIN.t23 XRX.XFRONT.XFE_E.XP.t33 XRX.XFRONT.XFE_E.XN.t31 VSS.t623 nfet_03v3 ad=2.08p pd=8.52u as=2.08p ps=8.52u w=8u l=0.28u
X682 VDD.t469 XRX.XFRONT.XFE_O.H.t25 XRX.XFRONT.XFE_O.HB.t13 VDD.t468 pfet_03v3 ad=2.08p pd=8.52u as=3.52p ps=16.88u w=8u l=0.28u
X683 a_n5052_n1000.t7 RX_BIAS.t6 VSS.t519 VSS.t517 nfet_03v3 ad=2.6p pd=10.52u as=2.6p ps=10.52u w=10u l=0.28u
X684 a_n10800_n23372.t1 TERM_EN0_N.t3 VDD.t247 VDD.t246 pfet_03v3 ad=0.88p pd=4.88u as=0.88p ps=4.88u w=2u l=0.28u
X685 XRX.XFRONT.XFE_O.NIP.t19 SAMP_O_P.t7 XRX.XFRONT.XFE_O.NTAIL.t8 VSS.t412 nfet_03v3 ad=3.52p pd=16.88u as=2.08p ps=8.52u w=8u l=0.28u
X686 XRX.XFRONT.XFE_E.XN.t7 XRX.XFRONT.XFE_E.XP.t36 XRX.XFRONT.XFE_E.NIN.t13 VSS.t111 nfet_03v3 ad=2.08p pd=8.52u as=2.08p ps=8.52u w=8u l=0.28u
X687 XRX.XFRONT.XFE_O.XP.t28 XRX.XFRONT.XFE_O.XN.t34 XRX.XFRONT.XFE_O.NIP.t22 VSS.t443 nfet_03v3 ad=2.08p pd=8.52u as=2.08p ps=8.52u w=8u l=0.28u
X688 XRX.XCAP.O_QI.t7 XRX.XCAP.ODD_DB_BUF.t16 XRX.XCAP.O_PSET_TAIL.t1 VDD.t0 pfet_03v3 ad=3.52p pd=16.88u as=2.08p ps=8.52u w=8u l=0.28u
X689 XRX.XFRONT.XFE_O.NIN.t13 O_SENSE_CLK.t17 VDD.t310 VDD.t309 pfet_03v3 ad=2.08p pd=8.52u as=2.08p ps=8.52u w=8u l=0.28u
X690 VSS.t553 O_SENSE_BOOST.t15 XRX.XFRONT.XFE_O.NTAIL.t29 VSS.t552 nfet_03v3 ad=2.6p pd=10.52u as=2.6p ps=10.52u w=10u l=0.28u
X691 VSS.t217 O_CAPTURE_CLK.t3 XRX.XCAP.O_RST_TAIL.t8 VSS.t102 nfet_03v3 ad=2.08p pd=8.52u as=2.08p ps=8.52u w=8u l=0.28u
X692 XRX.XFRONT.XFE_E.XP.t23 E_SENSE_CLK.t13 VDD.t221 VDD.t220 pfet_03v3 ad=2.08p pd=8.52u as=2.08p ps=8.52u w=8u l=0.28u
X693 a_72548_31500.t2 PHASE_A_N.t1 a_75604_31500.t0 VSS.t100 nfet_03v3 ad=1.3p pd=5.52u as=2.2p ps=10.88u w=5u l=0.28u
X694 a_n852_28800.t1 REST_BIAS.t6 VSS.t91 VSS.t90 nfet_03v3 ad=3.12p pd=12.52u as=3.12p ps=12.52u w=12u l=0.28u
X695 XRX.XFRONT.XFE_O.XN.t3 XRX.XFRONT.XFE_O.XP.t42 XRX.XFRONT.XFE_O.NIN.t2 VSS.t246 nfet_03v3 ad=2.08p pd=8.52u as=2.08p ps=8.52u w=8u l=0.28u
X696 XRX.XFRONT.XFE_E.H.t3 XRX.XFRONT.XFE_E.DP.t12 VSS.t585 VSS.t584 nfet_03v3 ad=2.08p pd=8.52u as=2.08p ps=8.52u w=8u l=0.28u
X697 XRX.XFRONT.XFE_O.NTAIL.t42 O_SENSE_BOOST.t2 VSS.t577 VSS.t576 nfet_03v3 ad=2.6p pd=10.52u as=2.6p ps=10.52u w=10u l=0.28u
X698 VSS.t472 XRX.XFRONT.XFE_O.DP.t7 XRX.XFRONT.XFE_O.H.t11 VSS.t471 nfet_03v3 ad=2.08p pd=8.52u as=2.08p ps=8.52u w=8u l=0.28u
X699 XRX.XFRONT.XFE_E.XP.t13 XRX.XFRONT.XFE_E.XN.t32 XRX.XFRONT.XFE_E.NIP.t11 VSS.t155 nfet_03v3 ad=3.52p pd=16.88u as=2.08p ps=8.52u w=8u l=0.28u
X700 VSS.t54 E_CAPTURE_CLK.t13 XRX.XCAP.E_SET_TAIL.t2 VSS.t53 nfet_03v3 ad=2.08p pd=8.52u as=2.08p ps=8.52u w=8u l=0.28u
X701 VDD.t410 E_CAPTURE_CLKB.t9 XRX.XCAP.E_PRST_TAIL.t8 VDD.t409 pfet_03v3 ad=2.08p pd=8.52u as=2.08p ps=8.52u w=8u l=0.28u
X702 VDD.t137 XRX.XCAP.O_QI.t19 XRX.XCAP.O_QBBUF.t2 VDD.t37 pfet_03v3 ad=2.08p pd=8.52u as=3.52p ps=16.88u w=8u l=0.28u
X703 a_n7300_n19900.t1 a_n10800_n19772.t3 a_n6400_n19852.t1 VSS.t243 nfet_03v3 ad=4.4p pd=20.88u as=2.6p ps=10.52u w=10u l=0.28u
X704 XRX.XFRONT.XFE_E.NTAIL.t30 E_SENSE_BOOST.t14 VSS.t318 VSS.t317 nfet_03v3 ad=2.6p pd=10.52u as=2.6p ps=10.52u w=10u l=0.28u
X705 XRX.XFRONT.XFE_O.HB.t0 XRX.XFRONT.XFE_O.H.t22 VDD.t169 VDD.t168 pfet_03v3 ad=3.52p pd=16.88u as=2.08p ps=8.52u w=8u l=0.28u
X706 VSS.t521 RX_BIAS.t9 a_n5052_n1000.t4 VSS.t520 nfet_03v3 ad=2.6p pd=10.52u as=4.4p ps=20.88u w=10u l=0.28u
X707 a_n6400_n23452.t0 RXN.t1 VSS.t40 ppolyf_u r_width=1u r_length=2.43u
X708 XRX.XFRONT.XFE_E.NIN.t2 XRX.XFRONT.XFE_E.XP.t39 XRX.XFRONT.XFE_E.XN.t4 VSS.t39 nfet_03v3 ad=2.08p pd=8.52u as=2.08p ps=8.52u w=8u l=0.28u
X709 a_n6400_n23452.t2 TERM_EN0_N.t0 a_n7157_n23500.t2 VDD.t249 pfet_03v3 ad=2.6p pd=10.52u as=4.4p ps=20.88u w=10u l=0.28u
X710 XRX.XCAP.EVEN_DB_BUF.t9 FE_E_P.t13 VDD.t93 VDD.t92 pfet_03v3 ad=2.08p pd=8.52u as=2.08p ps=8.52u w=8u l=0.28u
X711 XRX.XCAP.E_RST_TAIL.t9 XRX.XCAP.EVEN_DB_BUF.t13 XRX.XCAP.E_QI.t6 VSS.t55 nfet_03v3 ad=2.08p pd=8.52u as=2.08p ps=8.52u w=8u l=0.28u
X712 XRX.XFRONT.XFE_E.NTAIL.t15 SAMP_E_P.t12 XRX.XFRONT.XFE_E.NIN.t5 VSS.t80 nfet_03v3 ad=2.08p pd=8.52u as=2.08p ps=8.52u w=8u l=0.28u
X713 XRX.XFRONT.XFE_E.NTAIL.t42 E_SENSE_BOOST.t2 VSS.t342 VSS.t341 nfet_03v3 ad=2.6p pd=10.52u as=2.6p ps=10.52u w=10u l=0.28u
X714 XRX.XCAP.ODD_DB_BUF.t5 FE_O_P.t17 VDD.t66 VDD.t65 pfet_03v3 ad=2.08p pd=8.52u as=2.08p ps=8.52u w=8u l=0.28u
X715 XRX.XCAP.E_QBI.t9 XRX.XCAP.EVEN_D_BUF.t14 XRX.XCAP.E_SET_TAIL.t11 VSS.t62 nfet_03v3 ad=2.08p pd=8.52u as=2.08p ps=8.52u w=8u l=0.28u
X716 XRX.XCAP.O_RST_TAIL.t11 O_CAPTURE_CLK.t0 VSS.t223 VSS.t222 nfet_03v3 ad=3.52p pd=16.88u as=2.08p ps=8.52u w=8u l=0.28u
X717 XRX.XFRONT.XFE_O.XN.t14 O_SENSE_CLK.t26 XRX.XFRONT.XFE_O.XP.t25 VDD.t297 pfet_03v3 ad=2.08p pd=8.52u as=3.52p ps=16.88u w=8u l=0.28u
X718 XRX.XFRONT.XFE_O.NIN.t11 XRX.XFRONT.XFE_O.XP.t39 XRX.XFRONT.XFE_O.XN.t6 VSS.t354 nfet_03v3 ad=2.08p pd=8.52u as=2.08p ps=8.52u w=8u l=0.28u
X719 VSS.t338 E_SENSE_BOOST.t5 XRX.XFRONT.XFE_E.NTAIL.t39 VSS.t337 nfet_03v3 ad=2.6p pd=10.52u as=2.6p ps=10.52u w=10u l=0.28u
X720 a_n6400_n14452.t3 a_n10800_n14372.t2 a_n7300_n14500.t3 VSS.t383 nfet_03v3 ad=2.6p pd=10.52u as=4.4p ps=20.88u w=10u l=0.28u
X721 XRX.XCAP.O_PSET_TAIL.t7 O_CAPTURE_CLKB.t4 VDD.t126 VDD.t107 pfet_03v3 ad=2.08p pd=8.52u as=2.08p ps=8.52u w=8u l=0.28u
X722 FE_E_N.t1 XRX.XFRONT.XFE_E.H.t22 VDD.t139 VDD.t138 pfet_03v3 ad=3.52p pd=16.88u as=2.08p ps=8.52u w=8u l=0.28u
X723 VSS.t232 PI_CTRL_B.t1 a_74148_31500.t4 VSS.t231 nfet_03v3 ad=1.3p pd=5.52u as=1.3p ps=5.52u w=5u l=0.28u
X724 a_72404_31500.t3 PHASE_B_P.t0 a_74148_31500.t6 VSS.t505 nfet_03v3 ad=2.2p pd=10.88u as=1.3p ps=5.52u w=5u l=0.28u
X725 XRX.XFRONT.XFE_O.XP.t1 XRX.XFRONT.XFE_O.XN.t40 XRX.XFRONT.XFE_O.NIP.t1 VSS.t160 nfet_03v3 ad=2.08p pd=8.52u as=2.08p ps=8.52u w=8u l=0.28u
X726 XRX.XCAP.E_QI.t8 XRX.XCAP.E_QBI.t16 VDD.t339 VDD.t59 pfet_03v3 ad=3.52p pd=16.88u as=2.08p ps=8.52u w=8u l=0.28u
X727 XRX.XFRONT.XFE_O.DP.t2 XRX.XFRONT.XFE_O.XP.t46 VDD.t172 VDD.t171 pfet_03v3 ad=3.52p pd=16.88u as=2.08p ps=8.52u w=8u l=0.28u
X728 VSS.t357 XRX.XFRONT.XFE_O.DN.t11 XRX.XFRONT.XFE_O.HB.t4 VSS.t356 nfet_03v3 ad=2.08p pd=8.52u as=2.08p ps=8.52u w=8u l=0.28u
X729 VSS.t541 O_SENSE_BOOST.t21 XRX.XFRONT.XFE_O.NTAIL.t23 VSS.t540 nfet_03v3 ad=2.6p pd=10.52u as=2.6p ps=10.52u w=10u l=0.28u
X730 XRX.XFRONT.XFE_E.XN.t16 E_SENSE_CLK.t39 VDD.t179 VDD.t178 pfet_03v3 ad=2.08p pd=8.52u as=2.08p ps=8.52u w=8u l=0.28u
X731 VSS.t17 SAMP_BIAS.t1 a_11748_41600.t2 VSS.t16 nfet_03v3 ad=2.6p pd=10.52u as=2.6p ps=10.52u w=10u l=0.28u
X732 VDD.t55 a_75604_31500.t4 VSS.t133 ppolyf_u r_width=2u r_length=4u
X733 XRX.XFRONT.XFE_O.DN.t1 XRX.XFRONT.XFE_O.XN.t48 VDD.t104 VDD.t103 pfet_03v3 ad=2.08p pd=8.52u as=2.08p ps=8.52u w=8u l=0.28u
X734 VDD.t48 a_484_3500.t1 VSS.t123 ppolyf_u r_width=1u r_length=1.4u
X735 a_2548_44200.t2 SAMP_E_P.t6 SAMP_E_N.t1 VSS.t86 nfet_03v3 ad=1.56p pd=6.52u as=2.64p ps=12.88u w=6u l=0.28u
X736 VDD.t173 SAMP_O_N.t1 VSS.t261 ppolyf_u r_width=2u r_length=5u
X737 XRX.XFRONT.XFE_E.H.t9 XRX.XFRONT.XFE_E.DP.t6 VSS.t391 VSS.t390 nfet_03v3 ad=3.52p pd=16.88u as=2.08p ps=8.52u w=8u l=0.28u
X738 VDD.t424 E_CAPTURE_CLKB.t3 XRX.XCAP.E_PSET_TAIL.t8 VDD.t261 pfet_03v3 ad=2.08p pd=8.52u as=2.08p ps=8.52u w=8u l=0.28u
X739 XRX.XFRONT.XFE_E.NIP.t21 XRX.XFRONT.XFE_E.XN.t41 XRX.XFRONT.XFE_E.XP.t4 VSS.t484 nfet_03v3 ad=2.08p pd=8.52u as=2.08p ps=8.52u w=8u l=0.28u
X740 XRX.XFRONT.XFE_O.XN.t27 O_SENSE_CLK.t9 VDD.t324 VDD.t323 pfet_03v3 ad=2.08p pd=8.52u as=2.08p ps=8.52u w=8u l=0.28u
R0 TERM_EN0_N.n0 TERM_EN0_N.t1 139.688
R1 TERM_EN0_N.n0 TERM_EN0_N.t0 139.688
R2 TERM_EN0_N.n2 TERM_EN0_N.t3 62.9541
R3 TERM_EN0_N.n1 TERM_EN0_N.t2 49.9184
R4 TERM_EN0_N.n1 TERM_EN0_N.n0 22.445
R5 TERM_EN0_N.n2 TERM_EN0_N.n1 0.8735
R6 TERM_EN0_N TERM_EN0_N.n2 0.539857
R7 TERM_EN1_N.n0 TERM_EN1_N.t1 139.688
R8 TERM_EN1_N.n0 TERM_EN1_N.t0 139.688
R9 TERM_EN1_N.n2 TERM_EN1_N.t3 62.9541
R10 TERM_EN1_N.n1 TERM_EN1_N.t2 49.9184
R11 TERM_EN1_N.n1 TERM_EN1_N.n0 22.445
R12 TERM_EN1_N.n2 TERM_EN1_N.n1 0.8735
R13 TERM_EN1_N TERM_EN1_N.n2 0.539857
R14 TERM_EN2_N.n0 TERM_EN2_N.t1 139.688
R15 TERM_EN2_N.n0 TERM_EN2_N.t0 139.688
R16 TERM_EN2_N.n2 TERM_EN2_N.t3 62.9541
R17 TERM_EN2_N.n1 TERM_EN2_N.t2 49.9184
R18 TERM_EN2_N.n1 TERM_EN2_N.n0 22.445
R19 TERM_EN2_N.n2 TERM_EN2_N.n1 0.8735
R20 TERM_EN2_N TERM_EN2_N.n2 0.539857
R21 TERM_EN3_N.n0 TERM_EN3_N.t1 139.688
R22 TERM_EN3_N.n0 TERM_EN3_N.t0 139.688
R23 TERM_EN3_N.n2 TERM_EN3_N.t3 62.9541
R24 TERM_EN3_N.n1 TERM_EN3_N.t2 49.9184
R25 TERM_EN3_N.n1 TERM_EN3_N.n0 22.445
R26 TERM_EN3_N.n2 TERM_EN3_N.n1 0.8735
R27 TERM_EN3_N TERM_EN3_N.n2 0.539857
R28 TERM_EN4_N.n0 TERM_EN4_N.t1 139.688
R29 TERM_EN4_N.n0 TERM_EN4_N.t0 139.688
R30 TERM_EN4_N.n2 TERM_EN4_N.t3 62.9541
R31 TERM_EN4_N.n1 TERM_EN4_N.t2 49.9184
R32 TERM_EN4_N.n1 TERM_EN4_N.n0 22.445
R33 TERM_EN4_N.n2 TERM_EN4_N.n1 0.8735
R34 TERM_EN4_N TERM_EN4_N.n2 0.539857
R35 TERM_EN5_N.n0 TERM_EN5_N.t1 139.688
R36 TERM_EN5_N.n0 TERM_EN5_N.t0 139.688
R37 TERM_EN5_N.n2 TERM_EN5_N.t3 62.9541
R38 TERM_EN5_N.n1 TERM_EN5_N.t2 49.9184
R39 TERM_EN5_N.n1 TERM_EN5_N.n0 22.445
R40 TERM_EN5_N.n2 TERM_EN5_N.n1 0.8735
R41 TERM_EN5_N TERM_EN5_N.n2 0.539857
R42 TERM_EN6_N.n0 TERM_EN6_N.t1 139.688
R43 TERM_EN6_N.n0 TERM_EN6_N.t0 139.688
R44 TERM_EN6_N.n2 TERM_EN6_N.t3 62.9541
R45 TERM_EN6_N.n1 TERM_EN6_N.t2 49.9184
R46 TERM_EN6_N.n1 TERM_EN6_N.n0 22.445
R47 TERM_EN6_N.n2 TERM_EN6_N.n1 0.8735
R48 TERM_EN6_N TERM_EN6_N.n2 0.539857
R49 RXN.n0 RXN.t8 139.689
R50 RXN.n0 RXN.t9 139.689
R51 RXN.n1 RXN.n0 32.5563
R52 RXN.n2 RXN.t1 16.451
R53 RXN.n7 RXN.t3 15.7257
R54 RXN.n6 RXN.t4 15.7257
R55 RXN.n5 RXN.t0 15.7257
R56 RXN.n4 RXN.t5 15.7257
R57 RXN.n3 RXN.t2 15.7257
R58 RXN.n2 RXN.t6 15.641
R59 RXN.n1 RXN.t7 12.4583
R60 RXN.n3 RXN.n2 0.8105
R61 RXN.n4 RXN.n3 0.8105
R62 RXN.n5 RXN.n4 0.8105
R63 RXN.n6 RXN.n5 0.8105
R64 RXN.n7 RXN.n6 0.8105
R65 RXN RXN.n7 0.6305
R66 RXN RXN.n1 0.1805
R67 RXP.n0 RXP.t8 139.689
R68 RXP.n0 RXP.t9 139.689
R69 RXP.n1 RXP.n0 32.5563
R70 RXP.n2 RXP.t7 16.451
R71 RXP.n3 RXP.t1 15.7257
R72 RXP.n4 RXP.t4 15.7257
R73 RXP.n5 RXP.t2 15.7257
R74 RXP.n6 RXP.t5 15.7257
R75 RXP.n7 RXP.t3 15.7257
R76 RXP.n2 RXP.t0 15.641
R77 RXP.n1 RXP.t6 12.4583
R78 RXP.n3 RXP.n2 0.8105
R79 RXP.n4 RXP.n3 0.8105
R80 RXP.n5 RXP.n4 0.8105
R81 RXP.n6 RXP.n5 0.8105
R82 RXP.n7 RXP.n6 0.8105
R83 RXP RXP.n7 0.6305
R84 RXP RXP.n1 0.1805
R85 RX_BIAS.n4 RX_BIAS.t4 139.702
R86 RX_BIAS.n0 RX_BIAS.t0 139.702
R87 RX_BIAS.n15 RX_BIAS.t9 139.702
R88 RX_BIAS.n11 RX_BIAS.t5 139.702
R89 RX_BIAS.n1 RX_BIAS.t1 135.246
R90 RX_BIAS.n2 RX_BIAS.t2 135.246
R91 RX_BIAS.n3 RX_BIAS.t3 135.246
R92 RX_BIAS.n12 RX_BIAS.t6 135.246
R93 RX_BIAS.n13 RX_BIAS.t7 135.246
R94 RX_BIAS.n14 RX_BIAS.t8 135.246
R95 RX_BIAS.n6 RX_BIAS.t10 35.4171
R96 RX_BIAS.n9 RX_BIAS.t13 35.4171
R97 RX_BIAS.n7 RX_BIAS.t11 30.9603
R98 RX_BIAS.n8 RX_BIAS.t12 30.9603
R99 RX_BIAS.n17 RX_BIAS.n10 21.4384
R100 RX_BIAS.n18 RX_BIAS.n5 18.9479
R101 RX_BIAS.n5 RX_BIAS.n2 18.4942
R102 RX_BIAS.n16 RX_BIAS.n13 18.4942
R103 RX_BIAS.n17 RX_BIAS.n16 18.0005
R104 RX_BIAS.n8 RX_BIAS.n7 11.6805
R105 RX_BIAS.n2 RX_BIAS.n1 11.6805
R106 RX_BIAS.n3 RX_BIAS.n2 11.6805
R107 RX_BIAS.n13 RX_BIAS.n12 11.6805
R108 RX_BIAS.n14 RX_BIAS.n13 11.6805
R109 RX_BIAS RX_BIAS.n18 7.56892
R110 RX_BIAS.n5 RX_BIAS.n0 7.16487
R111 RX_BIAS.n5 RX_BIAS.n4 7.16487
R112 RX_BIAS.n16 RX_BIAS.n11 7.16487
R113 RX_BIAS.n16 RX_BIAS.n15 7.16487
R114 RX_BIAS.n10 RX_BIAS.n6 7.09873
R115 RX_BIAS.n10 RX_BIAS.n9 7.09873
R116 RX_BIAS.n7 RX_BIAS.n6 4.42851
R117 RX_BIAS.n9 RX_BIAS.n8 4.42851
R118 RX_BIAS.n1 RX_BIAS.n0 4.42851
R119 RX_BIAS.n4 RX_BIAS.n3 4.42851
R120 RX_BIAS.n12 RX_BIAS.n11 4.42851
R121 RX_BIAS.n15 RX_BIAS.n14 4.42851
R122 RX_BIAS.n18 RX_BIAS.n17 0.947868
R123 VTHN.n0 VTHN.t0 35.4171
R124 VTHN.n0 VTHN.t1 35.3883
R125 VTHN VTHN.n0 35.0111
R126 VTHP.n0 VTHP.t1 35.4171
R127 VTHP.n0 VTHP.t0 35.3883
R128 VTHP VTHP.n0 34.2271
R129 RX_BW_EN_N.n0 RX_BW_EN_N.t0 104.718
R130 RX_BW_EN_N.n2 RX_BW_EN_N.t3 102.35
R131 RX_BW_EN_N.n1 RX_BW_EN_N.t2 102.35
R132 RX_BW_EN_N.n0 RX_BW_EN_N.t1 102.35
R133 RX_BW_EN_N RX_BW_EN_N.n2 2.55971
R134 RX_BW_EN_N.n2 RX_BW_EN_N.n1 2.36892
R135 RX_BW_EN_N.n1 RX_BW_EN_N.n0 1.89524
R136 RX_RAWN.n0 RX_RAWN.t4 139.689
R137 RX_RAWN.n0 RX_RAWN.t5 139.689
R138 RX_RAWN RX_RAWN.n0 36.4661
R139 RX_RAWN.n3 RX_RAWN.t1 12.5711
R140 RX_RAWN.n2 RX_RAWN.t0 10.6142
R141 RX_RAWN RX_RAWN.n3 6.39524
R142 RX_RAWN.n1 RX_RAWN.t3 6.0676
R143 RX_RAWN.n1 RX_RAWN.t2 6.06436
R144 RX_RAWN.n2 RX_RAWN.n1 3.78254
R145 RX_RAWN.n3 RX_RAWN.n2 0.491409
R146 RX_RAWP.n0 RX_RAWP.t4 139.689
R147 RX_RAWP.n0 RX_RAWP.t5 139.689
R148 RX_RAWP RX_RAWP.n0 36.3761
R149 RX_RAWP.n3 RX_RAWP.t1 12.5711
R150 RX_RAWP.n2 RX_RAWP.t0 10.6142
R151 RX_RAWP RX_RAWP.n3 6.39524
R152 RX_RAWP.n1 RX_RAWP.t2 6.0676
R153 RX_RAWP.n1 RX_RAWP.t3 6.06436
R154 RX_RAWP.n2 RX_RAWP.n1 3.78254
R155 RX_RAWP.n3 RX_RAWP.n2 0.491409
R156 PI_CTRL_B.n0 PI_CTRL_B.t0 74.5242
R157 PI_CTRL_B.n3 PI_CTRL_B.t3 74.5242
R158 PI_CTRL_B.n1 PI_CTRL_B.t1 70.0675
R159 PI_CTRL_B.n2 PI_CTRL_B.t2 70.0675
R160 PI_CTRL_B PI_CTRL_B.n4 18.2966
R161 PI_CTRL_B.n2 PI_CTRL_B.n1 11.6805
R162 PI_CTRL_B.n4 PI_CTRL_B.n0 7.10487
R163 PI_CTRL_B.n4 PI_CTRL_B.n3 7.10487
R164 PI_CTRL_B.n1 PI_CTRL_B.n0 4.42851
R165 PI_CTRL_B.n3 PI_CTRL_B.n2 4.42851
R166 PI_CTRL_A.n0 PI_CTRL_A.t0 74.5242
R167 PI_CTRL_A.n3 PI_CTRL_A.t3 74.5242
R168 PI_CTRL_A.n1 PI_CTRL_A.t1 70.0675
R169 PI_CTRL_A.n2 PI_CTRL_A.t2 70.0675
R170 PI_CTRL_A PI_CTRL_A.n4 15.7505
R171 PI_CTRL_A.n2 PI_CTRL_A.n1 11.6805
R172 PI_CTRL_A.n4 PI_CTRL_A.n0 7.10487
R173 PI_CTRL_A.n4 PI_CTRL_A.n3 7.10487
R174 PI_CTRL_A.n1 PI_CTRL_A.n0 4.42851
R175 PI_CTRL_A.n3 PI_CTRL_A.n2 4.42851
R176 PI_BUF_BIAS.n0 PI_BUF_BIAS.t0 139.702
R177 PI_BUF_BIAS.n3 PI_BUF_BIAS.t3 139.702
R178 PI_BUF_BIAS.n1 PI_BUF_BIAS.t1 135.246
R179 PI_BUF_BIAS.n2 PI_BUF_BIAS.t2 135.246
R180 PI_BUF_BIAS PI_BUF_BIAS.n4 14.7439
R181 PI_BUF_BIAS.n2 PI_BUF_BIAS.n1 11.6805
R182 PI_BUF_BIAS.n4 PI_BUF_BIAS.n0 7.10487
R183 PI_BUF_BIAS.n4 PI_BUF_BIAS.n3 7.10487
R184 PI_BUF_BIAS.n1 PI_BUF_BIAS.n0 4.42851
R185 PI_BUF_BIAS.n3 PI_BUF_BIAS.n2 4.42851
R186 PHASE_A_N.n0 PHASE_A_N.t1 74.5104
R187 PHASE_A_N.n0 PHASE_A_N.t0 74.5104
R188 PHASE_A_N PHASE_A_N.n0 26.3041
R189 PHASE_B_N.n0 PHASE_B_N.t1 74.5104
R190 PHASE_B_N.n0 PHASE_B_N.t0 74.5104
R191 PHASE_B_N PHASE_B_N.n0 26.3041
R192 PHASE_B_P.n0 PHASE_B_P.t1 74.5104
R193 PHASE_B_P.n0 PHASE_B_P.t0 74.5104
R194 PHASE_B_P PHASE_B_P.n0 26.3041
R195 PHASE_A_P.n0 PHASE_A_P.t1 74.5104
R196 PHASE_A_P.n0 PHASE_A_P.t0 74.5104
R197 PHASE_A_P PHASE_A_P.n0 26.3041
R198 PI_RAW_N.n0 PI_RAW_N.t4 139.689
R199 PI_RAW_N.n0 PI_RAW_N.t3 139.689
R200 PI_RAW_N PI_RAW_N.n0 25.9298
R201 PI_RAW_N PI_RAW_N.n2 21.5831
R202 PI_RAW_N.n2 PI_RAW_N.t2 12.4637
R203 PI_RAW_N.n1 PI_RAW_N.t0 6.0676
R204 PI_RAW_N.n1 PI_RAW_N.t1 6.06436
R205 PI_RAW_N.n2 PI_RAW_N.n1 3.31209
R206 PI_RAW_P.n0 PI_RAW_P.t4 139.689
R207 PI_RAW_P.n0 PI_RAW_P.t3 139.689
R208 PI_RAW_P.n3 PI_RAW_P.n2 36.6078
R209 PI_RAW_P.n3 PI_RAW_P.n0 25.8876
R210 PI_RAW_P.n2 PI_RAW_P.t0 12.4637
R211 PI_RAW_P.n1 PI_RAW_P.t2 6.0676
R212 PI_RAW_P.n1 PI_RAW_P.t1 6.06436
R213 PI_RAW_P.n2 PI_RAW_P.n1 3.31209
R214 PI_RAW_P PI_RAW_P.n3 0.0426053
R215 REST_BIAS.n8 REST_BIAS.t3 165.774
R216 REST_BIAS.n5 REST_BIAS.t0 165.774
R217 REST_BIAS.n0 REST_BIAS.t4 165.774
R218 REST_BIAS.n3 REST_BIAS.t7 165.774
R219 REST_BIAS.n6 REST_BIAS.t1 161.317
R220 REST_BIAS.n7 REST_BIAS.t2 161.317
R221 REST_BIAS.n1 REST_BIAS.t5 161.317
R222 REST_BIAS.n2 REST_BIAS.t6 161.317
R223 REST_BIAS.n10 REST_BIAS.n4 19.0663
R224 REST_BIAS.n10 REST_BIAS.n9 13.5005
R225 REST_BIAS.n7 REST_BIAS.n6 11.6805
R226 REST_BIAS.n2 REST_BIAS.n1 11.6805
R227 REST_BIAS.n9 REST_BIAS.n5 7.10487
R228 REST_BIAS.n9 REST_BIAS.n8 7.10487
R229 REST_BIAS.n4 REST_BIAS.n0 7.10487
R230 REST_BIAS.n4 REST_BIAS.n3 7.10487
R231 REST_BIAS REST_BIAS.n10 6.38708
R232 REST_BIAS.n6 REST_BIAS.n5 4.42851
R233 REST_BIAS.n8 REST_BIAS.n7 4.42851
R234 REST_BIAS.n1 REST_BIAS.n0 4.42851
R235 REST_BIAS.n3 REST_BIAS.n2 4.42851
R236 CLK_REST_BIAS.n8 CLK_REST_BIAS.t3 165.774
R237 CLK_REST_BIAS.n5 CLK_REST_BIAS.t0 165.774
R238 CLK_REST_BIAS.n0 CLK_REST_BIAS.t4 165.774
R239 CLK_REST_BIAS.n3 CLK_REST_BIAS.t7 165.774
R240 CLK_REST_BIAS.n6 CLK_REST_BIAS.t1 161.317
R241 CLK_REST_BIAS.n7 CLK_REST_BIAS.t2 161.317
R242 CLK_REST_BIAS.n1 CLK_REST_BIAS.t5 161.317
R243 CLK_REST_BIAS.n2 CLK_REST_BIAS.t6 161.317
R244 CLK_REST_BIAS.n10 CLK_REST_BIAS.n4 19.0663
R245 CLK_REST_BIAS.n10 CLK_REST_BIAS.n9 13.5005
R246 CLK_REST_BIAS.n7 CLK_REST_BIAS.n6 11.6805
R247 CLK_REST_BIAS.n2 CLK_REST_BIAS.n1 11.6805
R248 CLK_REST_BIAS.n9 CLK_REST_BIAS.n5 7.10487
R249 CLK_REST_BIAS.n9 CLK_REST_BIAS.n8 7.10487
R250 CLK_REST_BIAS.n4 CLK_REST_BIAS.n0 7.10487
R251 CLK_REST_BIAS.n4 CLK_REST_BIAS.n3 7.10487
R252 CLK_REST_BIAS.n6 CLK_REST_BIAS.n5 4.42851
R253 CLK_REST_BIAS.n8 CLK_REST_BIAS.n7 4.42851
R254 CLK_REST_BIAS.n1 CLK_REST_BIAS.n0 4.42851
R255 CLK_REST_BIAS.n3 CLK_REST_BIAS.n2 4.42851
R256 CLK_REST_BIAS CLK_REST_BIAS.n10 0.250763
R257 SAMP_BIAS.n3 SAMP_BIAS.t3 139.702
R258 SAMP_BIAS.n0 SAMP_BIAS.t0 139.702
R259 SAMP_BIAS.n5 SAMP_BIAS.t4 139.702
R260 SAMP_BIAS.n8 SAMP_BIAS.t7 139.702
R261 SAMP_BIAS.n1 SAMP_BIAS.t1 135.246
R262 SAMP_BIAS.n2 SAMP_BIAS.t2 135.246
R263 SAMP_BIAS.n6 SAMP_BIAS.t5 135.246
R264 SAMP_BIAS.n7 SAMP_BIAS.t6 135.246
R265 SAMP_BIAS.n10 SAMP_BIAS.n4 19.1847
R266 SAMP_BIAS.n10 SAMP_BIAS.n9 13.5005
R267 SAMP_BIAS SAMP_BIAS.n10 12.8674
R268 SAMP_BIAS.n2 SAMP_BIAS.n1 11.6805
R269 SAMP_BIAS.n7 SAMP_BIAS.n6 11.6805
R270 SAMP_BIAS.n4 SAMP_BIAS.n0 7.10487
R271 SAMP_BIAS.n4 SAMP_BIAS.n3 7.10487
R272 SAMP_BIAS.n9 SAMP_BIAS.n5 7.10487
R273 SAMP_BIAS.n9 SAMP_BIAS.n8 7.10487
R274 SAMP_BIAS.n1 SAMP_BIAS.n0 4.42851
R275 SAMP_BIAS.n3 SAMP_BIAS.n2 4.42851
R276 SAMP_BIAS.n6 SAMP_BIAS.n5 4.42851
R277 SAMP_BIAS.n8 SAMP_BIAS.n7 4.42851
R278 PI_CLK_N.n0 PI_CLK_N.t5 113.618
R279 PI_CLK_N.n0 PI_CLK_N.t6 113.618
R280 PI_CLK_N.n1 PI_CLK_N.t3 113.618
R281 PI_CLK_N.n1 PI_CLK_N.t4 113.618
R282 PI_CLK_N.n2 PI_CLK_N.n1 25.1703
R283 PI_CLK_N.n2 PI_CLK_N.n0 20.9071
R284 PI_CLK_N PI_CLK_N.n4 17.198
R285 PI_CLK_N PI_CLK_N.n2 13.1737
R286 PI_CLK_N.n4 PI_CLK_N.t0 12.205
R287 PI_CLK_N.n3 PI_CLK_N.t1 6.0613
R288 PI_CLK_N.n3 PI_CLK_N.t2 6.0613
R289 PI_CLK_N.n4 PI_CLK_N.n3 2.97532
R290 PI_CLK_P.n0 PI_CLK_P.t5 113.618
R291 PI_CLK_P.n0 PI_CLK_P.t6 113.618
R292 PI_CLK_P.n1 PI_CLK_P.t3 113.618
R293 PI_CLK_P.n1 PI_CLK_P.t4 113.618
R294 PI_CLK_P.n2 PI_CLK_P.n1 28.3203
R295 PI_CLK_P.n2 PI_CLK_P.n0 25.1624
R296 PI_CLK_P PI_CLK_P.n4 20.0359
R297 PI_CLK_P.n4 PI_CLK_P.t0 12.205
R298 PI_CLK_P.n3 PI_CLK_P.t1 6.0613
R299 PI_CLK_P.n3 PI_CLK_P.t2 6.0613
R300 PI_CLK_P PI_CLK_P.n2 5.7105
R301 PI_CLK_P.n4 PI_CLK_P.n3 2.95032
R302 RX_RESTP.n1 RX_RESTP.t5 87.5461
R303 RX_RESTP.n1 RX_RESTP.t6 87.5461
R304 RX_RESTP.n0 RX_RESTP.t3 87.5461
R305 RX_RESTP.n0 RX_RESTP.t4 87.5461
R306 RX_RESTP.n2 RX_RESTP.n0 31.2488
R307 RX_RESTP.n2 RX_RESTP.n1 25.5646
R308 RX_RESTP RX_RESTP.n2 14.1979
R309 RX_RESTP.n4 RX_RESTP.t0 12.57
R310 RX_RESTP RX_RESTP.n4 11.8991
R311 RX_RESTP.n3 RX_RESTP.t1 6.0613
R312 RX_RESTP.n3 RX_RESTP.t2 6.0613
R313 RX_RESTP.n4 RX_RESTP.n3 2.77532
R314 RX_RESTN.n0 RX_RESTN.t5 87.5461
R315 RX_RESTN.n0 RX_RESTN.t6 87.5461
R316 RX_RESTN.n1 RX_RESTN.t3 87.5461
R317 RX_RESTN.n1 RX_RESTN.t4 87.5461
R318 RX_RESTN.n2 RX_RESTN.n1 22.0262
R319 RX_RESTN.n2 RX_RESTN.n0 16.342
R320 RX_RESTN.n4 RX_RESTN.t0 12.57
R321 RX_RESTN RX_RESTN.n4 9.30958
R322 RX_RESTN RX_RESTN.n2 9.17813
R323 RX_RESTN.n3 RX_RESTN.t1 6.0613
R324 RX_RESTN.n3 RX_RESTN.t2 6.0613
R325 RX_RESTN.n4 RX_RESTN.n3 2.77532
R326 O_SENSE_BOOST.t23 O_SENSE_BOOST.n52 153.859
R327 O_SENSE_BOOST.t0 O_SENSE_BOOST.n23 153.859
R328 O_SENSE_BOOST.t13 O_SENSE_BOOST.n38 153.739
R329 O_SENSE_BOOST.t15 O_SENSE_BOOST.n62 153.739
R330 O_SENSE_BOOST.n61 O_SENSE_BOOST.t16 153.739
R331 O_SENSE_BOOST.n52 O_SENSE_BOOST.t22 153.739
R332 O_SENSE_BOOST.n51 O_SENSE_BOOST.t21 153.739
R333 O_SENSE_BOOST.n50 O_SENSE_BOOST.t20 153.739
R334 O_SENSE_BOOST.n49 O_SENSE_BOOST.t19 153.739
R335 O_SENSE_BOOST.t18 O_SENSE_BOOST.n43 153.739
R336 O_SENSE_BOOST.n60 O_SENSE_BOOST.t17 153.739
R337 O_SENSE_BOOST.t14 O_SENSE_BOOST.n0 153.739
R338 O_SENSE_BOOST.n23 O_SENSE_BOOST.t1 153.739
R339 O_SENSE_BOOST.n22 O_SENSE_BOOST.t2 153.739
R340 O_SENSE_BOOST.n21 O_SENSE_BOOST.t3 153.739
R341 O_SENSE_BOOST.n20 O_SENSE_BOOST.t4 153.739
R342 O_SENSE_BOOST.n19 O_SENSE_BOOST.t5 153.739
R343 O_SENSE_BOOST.n18 O_SENSE_BOOST.t6 153.739
R344 O_SENSE_BOOST.n17 O_SENSE_BOOST.t7 153.739
R345 O_SENSE_BOOST.n16 O_SENSE_BOOST.t8 153.739
R346 O_SENSE_BOOST.n15 O_SENSE_BOOST.t9 153.739
R347 O_SENSE_BOOST.t10 O_SENSE_BOOST.n3 153.739
R348 O_SENSE_BOOST.n36 O_SENSE_BOOST.t11 153.739
R349 O_SENSE_BOOST.n37 O_SENSE_BOOST.t12 153.739
R350 O_SENSE_BOOST.n53 O_SENSE_BOOST.t23 139.702
R351 O_SENSE_BOOST.n24 O_SENSE_BOOST.t0 139.702
R352 O_SENSE_BOOST.n39 O_SENSE_BOOST.t13 135.246
R353 O_SENSE_BOOST.n63 O_SENSE_BOOST.t15 135.246
R354 O_SENSE_BOOST.t16 O_SENSE_BOOST.n42 135.246
R355 O_SENSE_BOOST.n54 O_SENSE_BOOST.t22 135.246
R356 O_SENSE_BOOST.n55 O_SENSE_BOOST.t21 135.246
R357 O_SENSE_BOOST.n56 O_SENSE_BOOST.t20 135.246
R358 O_SENSE_BOOST.n57 O_SENSE_BOOST.t19 135.246
R359 O_SENSE_BOOST.n58 O_SENSE_BOOST.t18 135.246
R360 O_SENSE_BOOST.t17 O_SENSE_BOOST.n59 135.246
R361 O_SENSE_BOOST.n40 O_SENSE_BOOST.t14 135.246
R362 O_SENSE_BOOST.n25 O_SENSE_BOOST.t1 135.246
R363 O_SENSE_BOOST.n26 O_SENSE_BOOST.t2 135.246
R364 O_SENSE_BOOST.n27 O_SENSE_BOOST.t3 135.246
R365 O_SENSE_BOOST.n28 O_SENSE_BOOST.t4 135.246
R366 O_SENSE_BOOST.n29 O_SENSE_BOOST.t5 135.246
R367 O_SENSE_BOOST.n30 O_SENSE_BOOST.t6 135.246
R368 O_SENSE_BOOST.n31 O_SENSE_BOOST.t7 135.246
R369 O_SENSE_BOOST.n32 O_SENSE_BOOST.t8 135.246
R370 O_SENSE_BOOST.n33 O_SENSE_BOOST.t9 135.246
R371 O_SENSE_BOOST.n34 O_SENSE_BOOST.t10 135.246
R372 O_SENSE_BOOST.t11 O_SENSE_BOOST.n35 135.246
R373 O_SENSE_BOOST.t12 O_SENSE_BOOST.n2 135.246
R374 O_SENSE_BOOST O_SENSE_BOOST.n66 31.5205
R375 O_SENSE_BOOST.n39 O_SENSE_BOOST.n1 18.4942
R376 O_SENSE_BOOST.n64 O_SENSE_BOOST.n63 18.4942
R377 O_SENSE_BOOST.n42 O_SENSE_BOOST.n41 18.4942
R378 O_SENSE_BOOST.n55 O_SENSE_BOOST.n48 18.4942
R379 O_SENSE_BOOST.n56 O_SENSE_BOOST.n47 18.4942
R380 O_SENSE_BOOST.n57 O_SENSE_BOOST.n46 18.4942
R381 O_SENSE_BOOST.n58 O_SENSE_BOOST.n45 18.4942
R382 O_SENSE_BOOST.n59 O_SENSE_BOOST.n44 18.4942
R383 O_SENSE_BOOST.n65 O_SENSE_BOOST.n40 18.4942
R384 O_SENSE_BOOST.n26 O_SENSE_BOOST.n14 18.4942
R385 O_SENSE_BOOST.n27 O_SENSE_BOOST.n13 18.4942
R386 O_SENSE_BOOST.n28 O_SENSE_BOOST.n12 18.4942
R387 O_SENSE_BOOST.n29 O_SENSE_BOOST.n11 18.4942
R388 O_SENSE_BOOST.n30 O_SENSE_BOOST.n10 18.4942
R389 O_SENSE_BOOST.n31 O_SENSE_BOOST.n9 18.4942
R390 O_SENSE_BOOST.n32 O_SENSE_BOOST.n8 18.4942
R391 O_SENSE_BOOST.n33 O_SENSE_BOOST.n7 18.4942
R392 O_SENSE_BOOST.n34 O_SENSE_BOOST.n6 18.4942
R393 O_SENSE_BOOST.n35 O_SENSE_BOOST.n5 18.4942
R394 O_SENSE_BOOST.n4 O_SENSE_BOOST.n2 18.4942
R395 O_SENSE_BOOST.n63 O_SENSE_BOOST.n40 11.6805
R396 O_SENSE_BOOST.n63 O_SENSE_BOOST.n42 11.6805
R397 O_SENSE_BOOST.n55 O_SENSE_BOOST.n54 11.6805
R398 O_SENSE_BOOST.n56 O_SENSE_BOOST.n55 11.6805
R399 O_SENSE_BOOST.n57 O_SENSE_BOOST.n56 11.6805
R400 O_SENSE_BOOST.n58 O_SENSE_BOOST.n57 11.6805
R401 O_SENSE_BOOST.n59 O_SENSE_BOOST.n58 11.6805
R402 O_SENSE_BOOST.n59 O_SENSE_BOOST.n42 11.6805
R403 O_SENSE_BOOST.n40 O_SENSE_BOOST.n39 11.6805
R404 O_SENSE_BOOST.n26 O_SENSE_BOOST.n25 11.6805
R405 O_SENSE_BOOST.n27 O_SENSE_BOOST.n26 11.6805
R406 O_SENSE_BOOST.n28 O_SENSE_BOOST.n27 11.6805
R407 O_SENSE_BOOST.n29 O_SENSE_BOOST.n28 11.6805
R408 O_SENSE_BOOST.n30 O_SENSE_BOOST.n29 11.6805
R409 O_SENSE_BOOST.n31 O_SENSE_BOOST.n30 11.6805
R410 O_SENSE_BOOST.n32 O_SENSE_BOOST.n31 11.6805
R411 O_SENSE_BOOST.n33 O_SENSE_BOOST.n32 11.6805
R412 O_SENSE_BOOST.n34 O_SENSE_BOOST.n33 11.6805
R413 O_SENSE_BOOST.n35 O_SENSE_BOOST.n34 11.6805
R414 O_SENSE_BOOST.n35 O_SENSE_BOOST.n2 11.6805
R415 O_SENSE_BOOST.n39 O_SENSE_BOOST.n2 11.6805
R416 O_SENSE_BOOST.n66 O_SENSE_BOOST.n65 10.3505
R417 O_SENSE_BOOST.n66 O_SENSE_BOOST.n0 9.88093
R418 O_SENSE_BOOST.n53 O_SENSE_BOOST.n48 7.17687
R419 O_SENSE_BOOST.n24 O_SENSE_BOOST.n14 7.17687
R420 O_SENSE_BOOST.n54 O_SENSE_BOOST.n53 4.42851
R421 O_SENSE_BOOST.n25 O_SENSE_BOOST.n24 4.42851
R422 O_SENSE_BOOST.n4 O_SENSE_BOOST.n1 0.1205
R423 O_SENSE_BOOST.n5 O_SENSE_BOOST.n4 0.1205
R424 O_SENSE_BOOST.n6 O_SENSE_BOOST.n5 0.1205
R425 O_SENSE_BOOST.n7 O_SENSE_BOOST.n6 0.1205
R426 O_SENSE_BOOST.n8 O_SENSE_BOOST.n7 0.1205
R427 O_SENSE_BOOST.n9 O_SENSE_BOOST.n8 0.1205
R428 O_SENSE_BOOST.n10 O_SENSE_BOOST.n9 0.1205
R429 O_SENSE_BOOST.n11 O_SENSE_BOOST.n10 0.1205
R430 O_SENSE_BOOST.n12 O_SENSE_BOOST.n11 0.1205
R431 O_SENSE_BOOST.n13 O_SENSE_BOOST.n12 0.1205
R432 O_SENSE_BOOST.n14 O_SENSE_BOOST.n13 0.1205
R433 O_SENSE_BOOST.n38 O_SENSE_BOOST.n37 0.1205
R434 O_SENSE_BOOST.n37 O_SENSE_BOOST.n36 0.1205
R435 O_SENSE_BOOST.n36 O_SENSE_BOOST.n3 0.1205
R436 O_SENSE_BOOST.n15 O_SENSE_BOOST.n3 0.1205
R437 O_SENSE_BOOST.n16 O_SENSE_BOOST.n15 0.1205
R438 O_SENSE_BOOST.n17 O_SENSE_BOOST.n16 0.1205
R439 O_SENSE_BOOST.n18 O_SENSE_BOOST.n17 0.1205
R440 O_SENSE_BOOST.n19 O_SENSE_BOOST.n18 0.1205
R441 O_SENSE_BOOST.n20 O_SENSE_BOOST.n19 0.1205
R442 O_SENSE_BOOST.n21 O_SENSE_BOOST.n20 0.1205
R443 O_SENSE_BOOST.n22 O_SENSE_BOOST.n21 0.1205
R444 O_SENSE_BOOST.n23 O_SENSE_BOOST.n22 0.1205
R445 O_SENSE_BOOST.n52 O_SENSE_BOOST.n51 0.1205
R446 O_SENSE_BOOST.n51 O_SENSE_BOOST.n50 0.1205
R447 O_SENSE_BOOST.n50 O_SENSE_BOOST.n49 0.1205
R448 O_SENSE_BOOST.n49 O_SENSE_BOOST.n43 0.1205
R449 O_SENSE_BOOST.n60 O_SENSE_BOOST.n43 0.1205
R450 O_SENSE_BOOST.n61 O_SENSE_BOOST.n60 0.1205
R451 O_SENSE_BOOST.n62 O_SENSE_BOOST.n61 0.1205
R452 O_SENSE_BOOST.n48 O_SENSE_BOOST.n47 0.1205
R453 O_SENSE_BOOST.n47 O_SENSE_BOOST.n46 0.1205
R454 O_SENSE_BOOST.n46 O_SENSE_BOOST.n45 0.1205
R455 O_SENSE_BOOST.n45 O_SENSE_BOOST.n44 0.1205
R456 O_SENSE_BOOST.n44 O_SENSE_BOOST.n41 0.1205
R457 O_SENSE_BOOST.n64 O_SENSE_BOOST.n41 0.1205
R458 O_SENSE_BOOST.n65 O_SENSE_BOOST.n1 0.1085
R459 O_SENSE_BOOST.n38 O_SENSE_BOOST.n0 0.1085
R460 O_SENSE_BOOST.n62 O_SENSE_BOOST.n0 0.1085
R461 O_SENSE_BOOST.n65 O_SENSE_BOOST.n64 0.1085
R462 SAMP_O_N.t7 SAMP_O_N.n17 127.788
R463 SAMP_O_N.t14 SAMP_O_N.n10 127.776
R464 SAMP_O_N.t12 SAMP_O_N.n24 127.668
R465 SAMP_O_N.t13 SAMP_O_N.n10 127.668
R466 SAMP_O_N.n17 SAMP_O_N.t8 127.668
R467 SAMP_O_N.t9 SAMP_O_N.n13 127.668
R468 SAMP_O_N.n22 SAMP_O_N.t10 127.668
R469 SAMP_O_N.n23 SAMP_O_N.t11 127.668
R470 SAMP_O_N.n18 SAMP_O_N.t7 113.632
R471 SAMP_O_N.n27 SAMP_O_N.t14 113.629
R472 SAMP_O_N.n25 SAMP_O_N.t12 109.174
R473 SAMP_O_N.n26 SAMP_O_N.t13 109.174
R474 SAMP_O_N.n19 SAMP_O_N.t8 109.174
R475 SAMP_O_N.n20 SAMP_O_N.t9 109.174
R476 SAMP_O_N.t10 SAMP_O_N.n21 109.174
R477 SAMP_O_N.t11 SAMP_O_N.n12 109.174
R478 SAMP_O_N.n1 SAMP_O_N.t5 87.5461
R479 SAMP_O_N.n1 SAMP_O_N.t6 87.5461
R480 SAMP_O_N.n30 SAMP_O_N.n29 45.2005
R481 SAMP_O_N.n2 SAMP_O_N.n1 26.3217
R482 SAMP_O_N.n25 SAMP_O_N.n11 18.4942
R483 SAMP_O_N.n20 SAMP_O_N.n16 18.4942
R484 SAMP_O_N.n21 SAMP_O_N.n15 18.4942
R485 SAMP_O_N.n14 SAMP_O_N.n12 18.4942
R486 SAMP_O_N.n30 SAMP_O_N.n9 14.125
R487 SAMP_O_N.n9 SAMP_O_N.t1 12.4596
R488 SAMP_O_N.n26 SAMP_O_N.n25 11.6805
R489 SAMP_O_N.n20 SAMP_O_N.n19 11.6805
R490 SAMP_O_N.n21 SAMP_O_N.n20 11.6805
R491 SAMP_O_N.n21 SAMP_O_N.n12 11.6805
R492 SAMP_O_N.n25 SAMP_O_N.n12 11.6805
R493 SAMP_O_N.n29 SAMP_O_N.n10 10.8396
R494 SAMP_O_N.n29 SAMP_O_N.n28 9.0005
R495 SAMP_O_N.n18 SAMP_O_N.n16 7.17687
R496 SAMP_O_N.n28 SAMP_O_N.n27 7.05405
R497 SAMP_O_N.n0 SAMP_O_N.t3 5.96544
R498 SAMP_O_N.n0 SAMP_O_N.t4 5.9622
R499 SAMP_O_N.n5 SAMP_O_N.t0 5.87051
R500 SAMP_O_N.n4 SAMP_O_N.t2 5.87051
R501 SAMP_O_N.n4 SAMP_O_N.n3 4.5005
R502 SAMP_O_N.n6 SAMP_O_N.n5 4.5005
R503 SAMP_O_N.n27 SAMP_O_N.n26 4.4296
R504 SAMP_O_N.n19 SAMP_O_N.n18 4.42851
R505 SAMP_O_N.n8 SAMP_O_N.n0 2.56391
R506 SAMP_O_N.n9 SAMP_O_N.n8 0.8805
R507 SAMP_O_N.n7 SAMP_O_N.n2 0.419
R508 SAMP_O_N.n8 SAMP_O_N.n7 0.2415
R509 SAMP_O_N.n5 SAMP_O_N.n4 0.189974
R510 SAMP_O_N.n6 SAMP_O_N.n3 0.1605
R511 SAMP_O_N.n14 SAMP_O_N.n11 0.1205
R512 SAMP_O_N.n15 SAMP_O_N.n14 0.1205
R513 SAMP_O_N.n16 SAMP_O_N.n15 0.1205
R514 SAMP_O_N.n24 SAMP_O_N.n23 0.1205
R515 SAMP_O_N.n23 SAMP_O_N.n22 0.1205
R516 SAMP_O_N.n22 SAMP_O_N.n13 0.1205
R517 SAMP_O_N.n17 SAMP_O_N.n13 0.1205
R518 SAMP_O_N.n28 SAMP_O_N.n11 0.1085
R519 SAMP_O_N.n24 SAMP_O_N.n10 0.1085
R520 SAMP_O_N SAMP_O_N.n30 0.0857632
R521 SAMP_O_N.n7 SAMP_O_N.n6 0.0795
R522 SAMP_O_N.n3 SAMP_O_N.n2 0.0740593
R523 SAMP_O_P.t14 SAMP_O_P.n18 127.788
R524 SAMP_O_P.t7 SAMP_O_P.n10 127.776
R525 SAMP_O_P.t9 SAMP_O_P.n25 127.668
R526 SAMP_O_P.n24 SAMP_O_P.t10 127.668
R527 SAMP_O_P.n18 SAMP_O_P.t13 127.668
R528 SAMP_O_P.t12 SAMP_O_P.n15 127.668
R529 SAMP_O_P.n23 SAMP_O_P.t11 127.668
R530 SAMP_O_P.t8 SAMP_O_P.n10 127.668
R531 SAMP_O_P.n19 SAMP_O_P.t14 113.632
R532 SAMP_O_P.n11 SAMP_O_P.t7 113.629
R533 SAMP_O_P.n26 SAMP_O_P.t9 109.174
R534 SAMP_O_P.t10 SAMP_O_P.n13 109.174
R535 SAMP_O_P.n20 SAMP_O_P.t13 109.174
R536 SAMP_O_P.n21 SAMP_O_P.t12 109.174
R537 SAMP_O_P.t11 SAMP_O_P.n22 109.174
R538 SAMP_O_P.n14 SAMP_O_P.t8 109.174
R539 SAMP_O_P.n0 SAMP_O_P.t5 87.5461
R540 SAMP_O_P.n0 SAMP_O_P.t6 87.5461
R541 SAMP_O_P.n1 SAMP_O_P.n0 35.3132
R542 SAMP_O_P SAMP_O_P.n29 32.8702
R543 SAMP_O_P.n27 SAMP_O_P.n26 18.4942
R544 SAMP_O_P.n13 SAMP_O_P.n12 18.4942
R545 SAMP_O_P.n21 SAMP_O_P.n17 18.4942
R546 SAMP_O_P.n22 SAMP_O_P.n16 18.4942
R547 SAMP_O_P SAMP_O_P.n9 14.2502
R548 SAMP_O_P.n9 SAMP_O_P.t0 12.4596
R549 SAMP_O_P.n26 SAMP_O_P.n14 11.6805
R550 SAMP_O_P.n26 SAMP_O_P.n13 11.6805
R551 SAMP_O_P.n21 SAMP_O_P.n20 11.6805
R552 SAMP_O_P.n22 SAMP_O_P.n21 11.6805
R553 SAMP_O_P.n22 SAMP_O_P.n13 11.6805
R554 SAMP_O_P.n29 SAMP_O_P.n10 10.8396
R555 SAMP_O_P.n29 SAMP_O_P.n28 9.0005
R556 SAMP_O_P.n19 SAMP_O_P.n17 7.17687
R557 SAMP_O_P.n28 SAMP_O_P.n11 7.05405
R558 SAMP_O_P.n7 SAMP_O_P.t4 5.96544
R559 SAMP_O_P.n7 SAMP_O_P.t3 5.9622
R560 SAMP_O_P.n3 SAMP_O_P.t1 5.87051
R561 SAMP_O_P.n4 SAMP_O_P.t2 5.87051
R562 SAMP_O_P.n5 SAMP_O_P.n4 4.5005
R563 SAMP_O_P.n3 SAMP_O_P.n2 4.5005
R564 SAMP_O_P.n14 SAMP_O_P.n11 4.4296
R565 SAMP_O_P.n20 SAMP_O_P.n19 4.42851
R566 SAMP_O_P.n8 SAMP_O_P.n7 2.56391
R567 SAMP_O_P.n9 SAMP_O_P.n8 0.8805
R568 SAMP_O_P.n6 SAMP_O_P.n1 0.419
R569 SAMP_O_P.n8 SAMP_O_P.n6 0.2415
R570 SAMP_O_P.n4 SAMP_O_P.n3 0.189974
R571 SAMP_O_P.n5 SAMP_O_P.n2 0.1605
R572 SAMP_O_P.n18 SAMP_O_P.n15 0.1205
R573 SAMP_O_P.n23 SAMP_O_P.n15 0.1205
R574 SAMP_O_P.n24 SAMP_O_P.n23 0.1205
R575 SAMP_O_P.n25 SAMP_O_P.n24 0.1205
R576 SAMP_O_P.n17 SAMP_O_P.n16 0.1205
R577 SAMP_O_P.n16 SAMP_O_P.n12 0.1205
R578 SAMP_O_P.n27 SAMP_O_P.n12 0.1205
R579 SAMP_O_P.n25 SAMP_O_P.n10 0.1085
R580 SAMP_O_P.n28 SAMP_O_P.n27 0.1085
R581 SAMP_O_P.n6 SAMP_O_P.n5 0.0795
R582 SAMP_O_P.n2 SAMP_O_P.n1 0.0405
R583 E_SENSE_BOOST.t23 E_SENSE_BOOST.n47 153.859
R584 E_SENSE_BOOST.t0 E_SENSE_BOOST.n13 153.859
R585 E_SENSE_BOOST.t8 E_SENSE_BOOST.n23 153.739
R586 E_SENSE_BOOST.t10 E_SENSE_BOOST.n62 153.739
R587 E_SENSE_BOOST.n61 E_SENSE_BOOST.t11 153.739
R588 E_SENSE_BOOST.n47 E_SENSE_BOOST.t22 153.739
R589 E_SENSE_BOOST.n46 E_SENSE_BOOST.t21 153.739
R590 E_SENSE_BOOST.n45 E_SENSE_BOOST.t20 153.739
R591 E_SENSE_BOOST.n44 E_SENSE_BOOST.t19 153.739
R592 E_SENSE_BOOST.n43 E_SENSE_BOOST.t18 153.739
R593 E_SENSE_BOOST.n42 E_SENSE_BOOST.t17 153.739
R594 E_SENSE_BOOST.n41 E_SENSE_BOOST.t16 153.739
R595 E_SENSE_BOOST.n40 E_SENSE_BOOST.t15 153.739
R596 E_SENSE_BOOST.n39 E_SENSE_BOOST.t14 153.739
R597 E_SENSE_BOOST.t13 E_SENSE_BOOST.n28 153.739
R598 E_SENSE_BOOST.n60 E_SENSE_BOOST.t12 153.739
R599 E_SENSE_BOOST.t9 E_SENSE_BOOST.n0 153.739
R600 E_SENSE_BOOST.n13 E_SENSE_BOOST.t1 153.739
R601 E_SENSE_BOOST.n12 E_SENSE_BOOST.t2 153.739
R602 E_SENSE_BOOST.n11 E_SENSE_BOOST.t3 153.739
R603 E_SENSE_BOOST.n10 E_SENSE_BOOST.t4 153.739
R604 E_SENSE_BOOST.t5 E_SENSE_BOOST.n3 153.739
R605 E_SENSE_BOOST.n21 E_SENSE_BOOST.t6 153.739
R606 E_SENSE_BOOST.n22 E_SENSE_BOOST.t7 153.739
R607 E_SENSE_BOOST.n48 E_SENSE_BOOST.t23 139.702
R608 E_SENSE_BOOST.n14 E_SENSE_BOOST.t0 139.702
R609 E_SENSE_BOOST.n24 E_SENSE_BOOST.t8 135.246
R610 E_SENSE_BOOST.n63 E_SENSE_BOOST.t10 135.246
R611 E_SENSE_BOOST.t11 E_SENSE_BOOST.n27 135.246
R612 E_SENSE_BOOST.n49 E_SENSE_BOOST.t22 135.246
R613 E_SENSE_BOOST.n50 E_SENSE_BOOST.t21 135.246
R614 E_SENSE_BOOST.n51 E_SENSE_BOOST.t20 135.246
R615 E_SENSE_BOOST.n52 E_SENSE_BOOST.t19 135.246
R616 E_SENSE_BOOST.n53 E_SENSE_BOOST.t18 135.246
R617 E_SENSE_BOOST.n54 E_SENSE_BOOST.t17 135.246
R618 E_SENSE_BOOST.n55 E_SENSE_BOOST.t16 135.246
R619 E_SENSE_BOOST.n56 E_SENSE_BOOST.t15 135.246
R620 E_SENSE_BOOST.n57 E_SENSE_BOOST.t14 135.246
R621 E_SENSE_BOOST.n58 E_SENSE_BOOST.t13 135.246
R622 E_SENSE_BOOST.t12 E_SENSE_BOOST.n59 135.246
R623 E_SENSE_BOOST.n25 E_SENSE_BOOST.t9 135.246
R624 E_SENSE_BOOST.n15 E_SENSE_BOOST.t1 135.246
R625 E_SENSE_BOOST.n16 E_SENSE_BOOST.t2 135.246
R626 E_SENSE_BOOST.n17 E_SENSE_BOOST.t3 135.246
R627 E_SENSE_BOOST.n18 E_SENSE_BOOST.t4 135.246
R628 E_SENSE_BOOST.n19 E_SENSE_BOOST.t5 135.246
R629 E_SENSE_BOOST.t6 E_SENSE_BOOST.n20 135.246
R630 E_SENSE_BOOST.t7 E_SENSE_BOOST.n2 135.246
R631 E_SENSE_BOOST E_SENSE_BOOST.n66 31.5205
R632 E_SENSE_BOOST.n24 E_SENSE_BOOST.n1 18.4942
R633 E_SENSE_BOOST.n64 E_SENSE_BOOST.n63 18.4942
R634 E_SENSE_BOOST.n27 E_SENSE_BOOST.n26 18.4942
R635 E_SENSE_BOOST.n50 E_SENSE_BOOST.n38 18.4942
R636 E_SENSE_BOOST.n51 E_SENSE_BOOST.n37 18.4942
R637 E_SENSE_BOOST.n52 E_SENSE_BOOST.n36 18.4942
R638 E_SENSE_BOOST.n53 E_SENSE_BOOST.n35 18.4942
R639 E_SENSE_BOOST.n54 E_SENSE_BOOST.n34 18.4942
R640 E_SENSE_BOOST.n55 E_SENSE_BOOST.n33 18.4942
R641 E_SENSE_BOOST.n56 E_SENSE_BOOST.n32 18.4942
R642 E_SENSE_BOOST.n57 E_SENSE_BOOST.n31 18.4942
R643 E_SENSE_BOOST.n58 E_SENSE_BOOST.n30 18.4942
R644 E_SENSE_BOOST.n59 E_SENSE_BOOST.n29 18.4942
R645 E_SENSE_BOOST.n65 E_SENSE_BOOST.n25 18.4942
R646 E_SENSE_BOOST.n16 E_SENSE_BOOST.n9 18.4942
R647 E_SENSE_BOOST.n17 E_SENSE_BOOST.n8 18.4942
R648 E_SENSE_BOOST.n18 E_SENSE_BOOST.n7 18.4942
R649 E_SENSE_BOOST.n19 E_SENSE_BOOST.n6 18.4942
R650 E_SENSE_BOOST.n20 E_SENSE_BOOST.n5 18.4942
R651 E_SENSE_BOOST.n4 E_SENSE_BOOST.n2 18.4942
R652 E_SENSE_BOOST.n63 E_SENSE_BOOST.n25 11.6805
R653 E_SENSE_BOOST.n63 E_SENSE_BOOST.n27 11.6805
R654 E_SENSE_BOOST.n50 E_SENSE_BOOST.n49 11.6805
R655 E_SENSE_BOOST.n51 E_SENSE_BOOST.n50 11.6805
R656 E_SENSE_BOOST.n52 E_SENSE_BOOST.n51 11.6805
R657 E_SENSE_BOOST.n53 E_SENSE_BOOST.n52 11.6805
R658 E_SENSE_BOOST.n54 E_SENSE_BOOST.n53 11.6805
R659 E_SENSE_BOOST.n55 E_SENSE_BOOST.n54 11.6805
R660 E_SENSE_BOOST.n56 E_SENSE_BOOST.n55 11.6805
R661 E_SENSE_BOOST.n57 E_SENSE_BOOST.n56 11.6805
R662 E_SENSE_BOOST.n58 E_SENSE_BOOST.n57 11.6805
R663 E_SENSE_BOOST.n59 E_SENSE_BOOST.n58 11.6805
R664 E_SENSE_BOOST.n59 E_SENSE_BOOST.n27 11.6805
R665 E_SENSE_BOOST.n25 E_SENSE_BOOST.n24 11.6805
R666 E_SENSE_BOOST.n16 E_SENSE_BOOST.n15 11.6805
R667 E_SENSE_BOOST.n17 E_SENSE_BOOST.n16 11.6805
R668 E_SENSE_BOOST.n18 E_SENSE_BOOST.n17 11.6805
R669 E_SENSE_BOOST.n19 E_SENSE_BOOST.n18 11.6805
R670 E_SENSE_BOOST.n20 E_SENSE_BOOST.n19 11.6805
R671 E_SENSE_BOOST.n20 E_SENSE_BOOST.n2 11.6805
R672 E_SENSE_BOOST.n24 E_SENSE_BOOST.n2 11.6805
R673 E_SENSE_BOOST.n66 E_SENSE_BOOST.n65 10.3505
R674 E_SENSE_BOOST.n66 E_SENSE_BOOST.n0 9.88093
R675 E_SENSE_BOOST.n48 E_SENSE_BOOST.n38 7.17687
R676 E_SENSE_BOOST.n14 E_SENSE_BOOST.n9 7.17687
R677 E_SENSE_BOOST.n49 E_SENSE_BOOST.n48 4.42851
R678 E_SENSE_BOOST.n15 E_SENSE_BOOST.n14 4.42851
R679 E_SENSE_BOOST.n4 E_SENSE_BOOST.n1 0.1205
R680 E_SENSE_BOOST.n5 E_SENSE_BOOST.n4 0.1205
R681 E_SENSE_BOOST.n6 E_SENSE_BOOST.n5 0.1205
R682 E_SENSE_BOOST.n7 E_SENSE_BOOST.n6 0.1205
R683 E_SENSE_BOOST.n8 E_SENSE_BOOST.n7 0.1205
R684 E_SENSE_BOOST.n9 E_SENSE_BOOST.n8 0.1205
R685 E_SENSE_BOOST.n23 E_SENSE_BOOST.n22 0.1205
R686 E_SENSE_BOOST.n22 E_SENSE_BOOST.n21 0.1205
R687 E_SENSE_BOOST.n21 E_SENSE_BOOST.n3 0.1205
R688 E_SENSE_BOOST.n10 E_SENSE_BOOST.n3 0.1205
R689 E_SENSE_BOOST.n11 E_SENSE_BOOST.n10 0.1205
R690 E_SENSE_BOOST.n12 E_SENSE_BOOST.n11 0.1205
R691 E_SENSE_BOOST.n13 E_SENSE_BOOST.n12 0.1205
R692 E_SENSE_BOOST.n47 E_SENSE_BOOST.n46 0.1205
R693 E_SENSE_BOOST.n46 E_SENSE_BOOST.n45 0.1205
R694 E_SENSE_BOOST.n45 E_SENSE_BOOST.n44 0.1205
R695 E_SENSE_BOOST.n44 E_SENSE_BOOST.n43 0.1205
R696 E_SENSE_BOOST.n43 E_SENSE_BOOST.n42 0.1205
R697 E_SENSE_BOOST.n42 E_SENSE_BOOST.n41 0.1205
R698 E_SENSE_BOOST.n41 E_SENSE_BOOST.n40 0.1205
R699 E_SENSE_BOOST.n40 E_SENSE_BOOST.n39 0.1205
R700 E_SENSE_BOOST.n39 E_SENSE_BOOST.n28 0.1205
R701 E_SENSE_BOOST.n60 E_SENSE_BOOST.n28 0.1205
R702 E_SENSE_BOOST.n61 E_SENSE_BOOST.n60 0.1205
R703 E_SENSE_BOOST.n62 E_SENSE_BOOST.n61 0.1205
R704 E_SENSE_BOOST.n38 E_SENSE_BOOST.n37 0.1205
R705 E_SENSE_BOOST.n37 E_SENSE_BOOST.n36 0.1205
R706 E_SENSE_BOOST.n36 E_SENSE_BOOST.n35 0.1205
R707 E_SENSE_BOOST.n35 E_SENSE_BOOST.n34 0.1205
R708 E_SENSE_BOOST.n34 E_SENSE_BOOST.n33 0.1205
R709 E_SENSE_BOOST.n33 E_SENSE_BOOST.n32 0.1205
R710 E_SENSE_BOOST.n32 E_SENSE_BOOST.n31 0.1205
R711 E_SENSE_BOOST.n31 E_SENSE_BOOST.n30 0.1205
R712 E_SENSE_BOOST.n30 E_SENSE_BOOST.n29 0.1205
R713 E_SENSE_BOOST.n29 E_SENSE_BOOST.n26 0.1205
R714 E_SENSE_BOOST.n64 E_SENSE_BOOST.n26 0.1205
R715 E_SENSE_BOOST.n65 E_SENSE_BOOST.n1 0.1085
R716 E_SENSE_BOOST.n23 E_SENSE_BOOST.n0 0.1085
R717 E_SENSE_BOOST.n62 E_SENSE_BOOST.n0 0.1085
R718 E_SENSE_BOOST.n65 E_SENSE_BOOST.n64 0.1085
R719 SAMP_E_N.t7 SAMP_E_N.n17 127.788
R720 SAMP_E_N.t14 SAMP_E_N.n10 127.776
R721 SAMP_E_N.t12 SAMP_E_N.n24 127.668
R722 SAMP_E_N.t13 SAMP_E_N.n10 127.668
R723 SAMP_E_N.n17 SAMP_E_N.t8 127.668
R724 SAMP_E_N.t9 SAMP_E_N.n13 127.668
R725 SAMP_E_N.n22 SAMP_E_N.t10 127.668
R726 SAMP_E_N.n23 SAMP_E_N.t11 127.668
R727 SAMP_E_N.n18 SAMP_E_N.t7 113.632
R728 SAMP_E_N.n27 SAMP_E_N.t14 113.629
R729 SAMP_E_N.n25 SAMP_E_N.t12 109.174
R730 SAMP_E_N.n26 SAMP_E_N.t13 109.174
R731 SAMP_E_N.n19 SAMP_E_N.t8 109.174
R732 SAMP_E_N.n20 SAMP_E_N.t9 109.174
R733 SAMP_E_N.t10 SAMP_E_N.n21 109.174
R734 SAMP_E_N.t11 SAMP_E_N.n12 109.174
R735 SAMP_E_N.n1 SAMP_E_N.t5 87.5461
R736 SAMP_E_N.n1 SAMP_E_N.t6 87.5461
R737 SAMP_E_N SAMP_E_N.n29 32.8702
R738 SAMP_E_N.n2 SAMP_E_N.n1 26.3484
R739 SAMP_E_N.n25 SAMP_E_N.n11 18.4942
R740 SAMP_E_N.n20 SAMP_E_N.n16 18.4942
R741 SAMP_E_N.n21 SAMP_E_N.n15 18.4942
R742 SAMP_E_N.n14 SAMP_E_N.n12 18.4942
R743 SAMP_E_N SAMP_E_N.n9 14.2502
R744 SAMP_E_N.n9 SAMP_E_N.t4 12.4596
R745 SAMP_E_N.n26 SAMP_E_N.n25 11.6805
R746 SAMP_E_N.n20 SAMP_E_N.n19 11.6805
R747 SAMP_E_N.n21 SAMP_E_N.n20 11.6805
R748 SAMP_E_N.n21 SAMP_E_N.n12 11.6805
R749 SAMP_E_N.n25 SAMP_E_N.n12 11.6805
R750 SAMP_E_N.n29 SAMP_E_N.n10 10.8396
R751 SAMP_E_N.n29 SAMP_E_N.n28 9.0005
R752 SAMP_E_N.n18 SAMP_E_N.n16 7.17687
R753 SAMP_E_N.n28 SAMP_E_N.n27 7.05405
R754 SAMP_E_N.n0 SAMP_E_N.t3 5.96544
R755 SAMP_E_N.n0 SAMP_E_N.t2 5.9622
R756 SAMP_E_N.n5 SAMP_E_N.t0 5.87051
R757 SAMP_E_N.n4 SAMP_E_N.t1 5.87051
R758 SAMP_E_N.n4 SAMP_E_N.n3 4.5005
R759 SAMP_E_N.n6 SAMP_E_N.n5 4.5005
R760 SAMP_E_N.n27 SAMP_E_N.n26 4.4296
R761 SAMP_E_N.n19 SAMP_E_N.n18 4.42851
R762 SAMP_E_N.n8 SAMP_E_N.n0 2.56391
R763 SAMP_E_N.n9 SAMP_E_N.n8 0.8805
R764 SAMP_E_N.n7 SAMP_E_N.n2 0.419
R765 SAMP_E_N.n8 SAMP_E_N.n7 0.2415
R766 SAMP_E_N.n5 SAMP_E_N.n4 0.189974
R767 SAMP_E_N.n6 SAMP_E_N.n3 0.1605
R768 SAMP_E_N.n14 SAMP_E_N.n11 0.1205
R769 SAMP_E_N.n15 SAMP_E_N.n14 0.1205
R770 SAMP_E_N.n16 SAMP_E_N.n15 0.1205
R771 SAMP_E_N.n24 SAMP_E_N.n23 0.1205
R772 SAMP_E_N.n23 SAMP_E_N.n22 0.1205
R773 SAMP_E_N.n22 SAMP_E_N.n13 0.1205
R774 SAMP_E_N.n17 SAMP_E_N.n13 0.1205
R775 SAMP_E_N.n28 SAMP_E_N.n11 0.1085
R776 SAMP_E_N.n24 SAMP_E_N.n10 0.1085
R777 SAMP_E_N.n7 SAMP_E_N.n6 0.0795
R778 SAMP_E_N.n3 SAMP_E_N.n2 0.0405
R779 SAMP_E_P.t14 SAMP_E_P.n18 127.788
R780 SAMP_E_P.t7 SAMP_E_P.n10 127.776
R781 SAMP_E_P.t9 SAMP_E_P.n25 127.668
R782 SAMP_E_P.n24 SAMP_E_P.t10 127.668
R783 SAMP_E_P.n18 SAMP_E_P.t13 127.668
R784 SAMP_E_P.t12 SAMP_E_P.n15 127.668
R785 SAMP_E_P.n23 SAMP_E_P.t11 127.668
R786 SAMP_E_P.t8 SAMP_E_P.n10 127.668
R787 SAMP_E_P.n19 SAMP_E_P.t14 113.632
R788 SAMP_E_P.n11 SAMP_E_P.t7 113.629
R789 SAMP_E_P.n26 SAMP_E_P.t9 109.174
R790 SAMP_E_P.t10 SAMP_E_P.n13 109.174
R791 SAMP_E_P.n20 SAMP_E_P.t13 109.174
R792 SAMP_E_P.n21 SAMP_E_P.t12 109.174
R793 SAMP_E_P.t11 SAMP_E_P.n22 109.174
R794 SAMP_E_P.n14 SAMP_E_P.t8 109.174
R795 SAMP_E_P.n0 SAMP_E_P.t5 87.5461
R796 SAMP_E_P.n0 SAMP_E_P.t6 87.5461
R797 SAMP_E_P.n30 SAMP_E_P.n29 45.2005
R798 SAMP_E_P.n1 SAMP_E_P.n0 35.155
R799 SAMP_E_P.n27 SAMP_E_P.n26 18.4942
R800 SAMP_E_P.n13 SAMP_E_P.n12 18.4942
R801 SAMP_E_P.n21 SAMP_E_P.n17 18.4942
R802 SAMP_E_P.n22 SAMP_E_P.n16 18.4942
R803 SAMP_E_P.n30 SAMP_E_P.n9 14.125
R804 SAMP_E_P.n9 SAMP_E_P.t2 12.4596
R805 SAMP_E_P.n26 SAMP_E_P.n14 11.6805
R806 SAMP_E_P.n26 SAMP_E_P.n13 11.6805
R807 SAMP_E_P.n21 SAMP_E_P.n20 11.6805
R808 SAMP_E_P.n22 SAMP_E_P.n21 11.6805
R809 SAMP_E_P.n22 SAMP_E_P.n13 11.6805
R810 SAMP_E_P.n29 SAMP_E_P.n10 10.8396
R811 SAMP_E_P.n29 SAMP_E_P.n28 9.0005
R812 SAMP_E_P.n19 SAMP_E_P.n17 7.17687
R813 SAMP_E_P.n28 SAMP_E_P.n11 7.05405
R814 SAMP_E_P.n7 SAMP_E_P.t3 5.96544
R815 SAMP_E_P.n7 SAMP_E_P.t4 5.9622
R816 SAMP_E_P.n3 SAMP_E_P.t1 5.87051
R817 SAMP_E_P.n4 SAMP_E_P.t0 5.87051
R818 SAMP_E_P.n5 SAMP_E_P.n4 4.5005
R819 SAMP_E_P.n3 SAMP_E_P.n2 4.5005
R820 SAMP_E_P.n14 SAMP_E_P.n11 4.4296
R821 SAMP_E_P.n20 SAMP_E_P.n19 4.42851
R822 SAMP_E_P.n8 SAMP_E_P.n7 2.56391
R823 SAMP_E_P.n9 SAMP_E_P.n8 0.8805
R824 SAMP_E_P.n6 SAMP_E_P.n1 0.419
R825 SAMP_E_P.n8 SAMP_E_P.n6 0.2415
R826 SAMP_E_P.n4 SAMP_E_P.n3 0.189974
R827 SAMP_E_P.n5 SAMP_E_P.n2 0.1605
R828 SAMP_E_P.n18 SAMP_E_P.n15 0.1205
R829 SAMP_E_P.n23 SAMP_E_P.n15 0.1205
R830 SAMP_E_P.n24 SAMP_E_P.n23 0.1205
R831 SAMP_E_P.n25 SAMP_E_P.n24 0.1205
R832 SAMP_E_P.n17 SAMP_E_P.n16 0.1205
R833 SAMP_E_P.n16 SAMP_E_P.n12 0.1205
R834 SAMP_E_P.n27 SAMP_E_P.n12 0.1205
R835 SAMP_E_P.n25 SAMP_E_P.n10 0.1085
R836 SAMP_E_P.n28 SAMP_E_P.n27 0.1085
R837 SAMP_E_P SAMP_E_P.n30 0.0857632
R838 SAMP_E_P.n6 SAMP_E_P.n5 0.0795
R839 SAMP_E_P.n2 SAMP_E_P.n1 0.0740593
R840 O_SENSE_CLK.n58 O_SENSE_CLK.t0 139.702
R841 O_SENSE_CLK.n60 O_SENSE_CLK.t2 135.246
R842 O_SENSE_CLK.n61 O_SENSE_CLK.t3 135.246
R843 O_SENSE_CLK.n62 O_SENSE_CLK.t4 135.246
R844 O_SENSE_CLK.n57 O_SENSE_CLK.t1 135.246
R845 O_SENSE_CLK.t14 O_SENSE_CLK.n8 127.788
R846 O_SENSE_CLK.t26 O_SENSE_CLK.n45 127.788
R847 O_SENSE_CLK.t31 O_SENSE_CLK.n87 127.788
R848 O_SENSE_CLK.t19 O_SENSE_CLK.n35 127.776
R849 O_SENSE_CLK.t5 O_SENSE_CLK.n0 127.668
R850 O_SENSE_CLK.t6 O_SENSE_CLK.n23 127.668
R851 O_SENSE_CLK.n22 O_SENSE_CLK.t7 127.668
R852 O_SENSE_CLK.n21 O_SENSE_CLK.t8 127.668
R853 O_SENSE_CLK.t9 O_SENSE_CLK.n3 127.668
R854 O_SENSE_CLK.t10 O_SENSE_CLK.n15 127.668
R855 O_SENSE_CLK.n14 O_SENSE_CLK.t11 127.668
R856 O_SENSE_CLK.n13 O_SENSE_CLK.t12 127.668
R857 O_SENSE_CLK.t13 O_SENSE_CLK.n8 127.668
R858 O_SENSE_CLK.n45 O_SENSE_CLK.t25 127.668
R859 O_SENSE_CLK.n44 O_SENSE_CLK.t24 127.668
R860 O_SENSE_CLK.n43 O_SENSE_CLK.t23 127.668
R861 O_SENSE_CLK.n42 O_SENSE_CLK.t22 127.668
R862 O_SENSE_CLK.n41 O_SENSE_CLK.t21 127.668
R863 O_SENSE_CLK.t20 O_SENSE_CLK.n35 127.668
R864 O_SENSE_CLK.t40 O_SENSE_CLK.n72 127.668
R865 O_SENSE_CLK.n87 O_SENSE_CLK.t32 127.668
R866 O_SENSE_CLK.n86 O_SENSE_CLK.t33 127.668
R867 O_SENSE_CLK.n85 O_SENSE_CLK.t34 127.668
R868 O_SENSE_CLK.n84 O_SENSE_CLK.t35 127.668
R869 O_SENSE_CLK.n83 O_SENSE_CLK.t36 127.668
R870 O_SENSE_CLK.n82 O_SENSE_CLK.t37 127.668
R871 O_SENSE_CLK.n81 O_SENSE_CLK.t38 127.668
R872 O_SENSE_CLK.n80 O_SENSE_CLK.t39 127.668
R873 O_SENSE_CLK.n29 O_SENSE_CLK.t18 113.632
R874 O_SENSE_CLK.n10 O_SENSE_CLK.t14 113.632
R875 O_SENSE_CLK.n66 O_SENSE_CLK.t30 113.632
R876 O_SENSE_CLK.n46 O_SENSE_CLK.t26 113.632
R877 O_SENSE_CLK.n88 O_SENSE_CLK.t31 113.632
R878 O_SENSE_CLK.n36 O_SENSE_CLK.t19 113.629
R879 O_SENSE_CLK.n30 O_SENSE_CLK.t17 109.174
R880 O_SENSE_CLK.n31 O_SENSE_CLK.t16 109.174
R881 O_SENSE_CLK.n28 O_SENSE_CLK.t15 109.174
R882 O_SENSE_CLK.n25 O_SENSE_CLK.t5 109.174
R883 O_SENSE_CLK.n24 O_SENSE_CLK.t6 109.174
R884 O_SENSE_CLK.t7 O_SENSE_CLK.n2 109.174
R885 O_SENSE_CLK.t8 O_SENSE_CLK.n20 109.174
R886 O_SENSE_CLK.n4 O_SENSE_CLK.t9 109.174
R887 O_SENSE_CLK.n16 O_SENSE_CLK.t10 109.174
R888 O_SENSE_CLK.t11 O_SENSE_CLK.n7 109.174
R889 O_SENSE_CLK.t12 O_SENSE_CLK.n12 109.174
R890 O_SENSE_CLK.n9 O_SENSE_CLK.t13 109.174
R891 O_SENSE_CLK.n67 O_SENSE_CLK.t29 109.174
R892 O_SENSE_CLK.n68 O_SENSE_CLK.t28 109.174
R893 O_SENSE_CLK.n65 O_SENSE_CLK.t27 109.174
R894 O_SENSE_CLK.t25 O_SENSE_CLK.n40 109.174
R895 O_SENSE_CLK.n48 O_SENSE_CLK.t24 109.174
R896 O_SENSE_CLK.n49 O_SENSE_CLK.t23 109.174
R897 O_SENSE_CLK.n50 O_SENSE_CLK.t22 109.174
R898 O_SENSE_CLK.n51 O_SENSE_CLK.t21 109.174
R899 O_SENSE_CLK.n38 O_SENSE_CLK.t20 109.174
R900 O_SENSE_CLK.n97 O_SENSE_CLK.t40 109.174
R901 O_SENSE_CLK.n89 O_SENSE_CLK.t32 109.174
R902 O_SENSE_CLK.n90 O_SENSE_CLK.t33 109.174
R903 O_SENSE_CLK.n91 O_SENSE_CLK.t34 109.174
R904 O_SENSE_CLK.n92 O_SENSE_CLK.t35 109.174
R905 O_SENSE_CLK.n93 O_SENSE_CLK.t36 109.174
R906 O_SENSE_CLK.n94 O_SENSE_CLK.t37 109.174
R907 O_SENSE_CLK.n95 O_SENSE_CLK.t38 109.174
R908 O_SENSE_CLK.n96 O_SENSE_CLK.t39 109.174
R909 O_SENSE_CLK.n34 O_SENSE_CLK.n33 24.5548
R910 O_SENSE_CLK.n71 O_SENSE_CLK.n70 24.5548
R911 O_SENSE_CLK.n34 O_SENSE_CLK.n27 20.0548
R912 O_SENSE_CLK.n63 O_SENSE_CLK.n62 18.5723
R913 O_SENSE_CLK.n33 O_SENSE_CLK.n28 18.5179
R914 O_SENSE_CLK.n70 O_SENSE_CLK.n65 18.5179
R915 O_SENSE_CLK.n32 O_SENSE_CLK.n31 18.4942
R916 O_SENSE_CLK.n60 O_SENSE_CLK.n59 18.4942
R917 O_SENSE_CLK.n61 O_SENSE_CLK.n56 18.4942
R918 O_SENSE_CLK.n26 O_SENSE_CLK.n25 18.4942
R919 O_SENSE_CLK.n24 O_SENSE_CLK.n1 18.4942
R920 O_SENSE_CLK.n5 O_SENSE_CLK.n2 18.4942
R921 O_SENSE_CLK.n20 O_SENSE_CLK.n19 18.4942
R922 O_SENSE_CLK.n18 O_SENSE_CLK.n4 18.4942
R923 O_SENSE_CLK.n17 O_SENSE_CLK.n16 18.4942
R924 O_SENSE_CLK.n7 O_SENSE_CLK.n6 18.4942
R925 O_SENSE_CLK.n12 O_SENSE_CLK.n11 18.4942
R926 O_SENSE_CLK.n69 O_SENSE_CLK.n68 18.4942
R927 O_SENSE_CLK.n48 O_SENSE_CLK.n47 18.4942
R928 O_SENSE_CLK.n49 O_SENSE_CLK.n39 18.4942
R929 O_SENSE_CLK.n50 O_SENSE_CLK.n37 18.4942
R930 O_SENSE_CLK.n52 O_SENSE_CLK.n51 18.4942
R931 O_SENSE_CLK.n98 O_SENSE_CLK.n97 18.4942
R932 O_SENSE_CLK.n90 O_SENSE_CLK.n79 18.4942
R933 O_SENSE_CLK.n91 O_SENSE_CLK.n78 18.4942
R934 O_SENSE_CLK.n92 O_SENSE_CLK.n77 18.4942
R935 O_SENSE_CLK.n93 O_SENSE_CLK.n76 18.4942
R936 O_SENSE_CLK.n94 O_SENSE_CLK.n75 18.4942
R937 O_SENSE_CLK.n95 O_SENSE_CLK.n74 18.4942
R938 O_SENSE_CLK.n96 O_SENSE_CLK.n73 18.4942
R939 O_SENSE_CLK.n55 O_SENSE_CLK.n54 15.5548
R940 O_SENSE_CLK.n100 O_SENSE_CLK.n99 15.5548
R941 O_SENSE_CLK.n64 O_SENSE_CLK.n63 14.5766
R942 O_SENSE_CLK O_SENSE_CLK.n100 13.9118
R943 O_SENSE_CLK.n31 O_SENSE_CLK.n30 11.6805
R944 O_SENSE_CLK.n31 O_SENSE_CLK.n28 11.6805
R945 O_SENSE_CLK.n60 O_SENSE_CLK.n57 11.6805
R946 O_SENSE_CLK.n61 O_SENSE_CLK.n60 11.6805
R947 O_SENSE_CLK.n62 O_SENSE_CLK.n61 11.6805
R948 O_SENSE_CLK.n25 O_SENSE_CLK.n24 11.6805
R949 O_SENSE_CLK.n24 O_SENSE_CLK.n2 11.6805
R950 O_SENSE_CLK.n20 O_SENSE_CLK.n2 11.6805
R951 O_SENSE_CLK.n20 O_SENSE_CLK.n4 11.6805
R952 O_SENSE_CLK.n16 O_SENSE_CLK.n4 11.6805
R953 O_SENSE_CLK.n16 O_SENSE_CLK.n7 11.6805
R954 O_SENSE_CLK.n12 O_SENSE_CLK.n7 11.6805
R955 O_SENSE_CLK.n12 O_SENSE_CLK.n9 11.6805
R956 O_SENSE_CLK.n68 O_SENSE_CLK.n67 11.6805
R957 O_SENSE_CLK.n68 O_SENSE_CLK.n65 11.6805
R958 O_SENSE_CLK.n49 O_SENSE_CLK.n48 11.6805
R959 O_SENSE_CLK.n48 O_SENSE_CLK.n40 11.6805
R960 O_SENSE_CLK.n50 O_SENSE_CLK.n49 11.6805
R961 O_SENSE_CLK.n51 O_SENSE_CLK.n50 11.6805
R962 O_SENSE_CLK.n51 O_SENSE_CLK.n38 11.6805
R963 O_SENSE_CLK.n90 O_SENSE_CLK.n89 11.6805
R964 O_SENSE_CLK.n91 O_SENSE_CLK.n90 11.6805
R965 O_SENSE_CLK.n92 O_SENSE_CLK.n91 11.6805
R966 O_SENSE_CLK.n93 O_SENSE_CLK.n92 11.6805
R967 O_SENSE_CLK.n94 O_SENSE_CLK.n93 11.6805
R968 O_SENSE_CLK.n95 O_SENSE_CLK.n94 11.6805
R969 O_SENSE_CLK.n96 O_SENSE_CLK.n95 11.6805
R970 O_SENSE_CLK.n97 O_SENSE_CLK.n96 11.6805
R971 O_SENSE_CLK.n27 O_SENSE_CLK.n0 11.1876
R972 O_SENSE_CLK.n99 O_SENSE_CLK.n72 11.0376
R973 O_SENSE_CLK.n54 O_SENSE_CLK.n35 10.8396
R974 O_SENSE_CLK.n27 O_SENSE_CLK.n26 9.3485
R975 O_SENSE_CLK.n99 O_SENSE_CLK.n98 9.1985
R976 O_SENSE_CLK.n54 O_SENSE_CLK.n53 9.0005
R977 O_SENSE_CLK.n32 O_SENSE_CLK.n29 7.17687
R978 O_SENSE_CLK.n59 O_SENSE_CLK.n58 7.17687
R979 O_SENSE_CLK.n11 O_SENSE_CLK.n10 7.17687
R980 O_SENSE_CLK.n69 O_SENSE_CLK.n66 7.17687
R981 O_SENSE_CLK.n47 O_SENSE_CLK.n46 7.17687
R982 O_SENSE_CLK.n88 O_SENSE_CLK.n79 7.17687
R983 O_SENSE_CLK.n53 O_SENSE_CLK.n36 7.05405
R984 O_SENSE_CLK.n100 O_SENSE_CLK.n71 4.69615
R985 O_SENSE_CLK.n38 O_SENSE_CLK.n36 4.4296
R986 O_SENSE_CLK.n30 O_SENSE_CLK.n29 4.42851
R987 O_SENSE_CLK.n58 O_SENSE_CLK.n57 4.42851
R988 O_SENSE_CLK.n10 O_SENSE_CLK.n9 4.42851
R989 O_SENSE_CLK.n67 O_SENSE_CLK.n66 4.42851
R990 O_SENSE_CLK.n46 O_SENSE_CLK.n40 4.42851
R991 O_SENSE_CLK.n89 O_SENSE_CLK.n88 4.42851
R992 O_SENSE_CLK.n55 O_SENSE_CLK.n34 3.32659
R993 O_SENSE_CLK.n71 O_SENSE_CLK.n64 2.73963
R994 O_SENSE_CLK.n64 O_SENSE_CLK.n55 0.978761
R995 O_SENSE_CLK.n11 O_SENSE_CLK.n6 0.1205
R996 O_SENSE_CLK.n17 O_SENSE_CLK.n6 0.1205
R997 O_SENSE_CLK.n18 O_SENSE_CLK.n17 0.1205
R998 O_SENSE_CLK.n19 O_SENSE_CLK.n18 0.1205
R999 O_SENSE_CLK.n19 O_SENSE_CLK.n5 0.1205
R1000 O_SENSE_CLK.n5 O_SENSE_CLK.n1 0.1205
R1001 O_SENSE_CLK.n26 O_SENSE_CLK.n1 0.1205
R1002 O_SENSE_CLK.n13 O_SENSE_CLK.n8 0.1205
R1003 O_SENSE_CLK.n14 O_SENSE_CLK.n13 0.1205
R1004 O_SENSE_CLK.n15 O_SENSE_CLK.n14 0.1205
R1005 O_SENSE_CLK.n15 O_SENSE_CLK.n3 0.1205
R1006 O_SENSE_CLK.n21 O_SENSE_CLK.n3 0.1205
R1007 O_SENSE_CLK.n22 O_SENSE_CLK.n21 0.1205
R1008 O_SENSE_CLK.n23 O_SENSE_CLK.n22 0.1205
R1009 O_SENSE_CLK.n23 O_SENSE_CLK.n0 0.1205
R1010 O_SENSE_CLK.n45 O_SENSE_CLK.n44 0.1205
R1011 O_SENSE_CLK.n44 O_SENSE_CLK.n43 0.1205
R1012 O_SENSE_CLK.n43 O_SENSE_CLK.n42 0.1205
R1013 O_SENSE_CLK.n42 O_SENSE_CLK.n41 0.1205
R1014 O_SENSE_CLK.n47 O_SENSE_CLK.n39 0.1205
R1015 O_SENSE_CLK.n39 O_SENSE_CLK.n37 0.1205
R1016 O_SENSE_CLK.n52 O_SENSE_CLK.n37 0.1205
R1017 O_SENSE_CLK.n98 O_SENSE_CLK.n73 0.1205
R1018 O_SENSE_CLK.n74 O_SENSE_CLK.n73 0.1205
R1019 O_SENSE_CLK.n75 O_SENSE_CLK.n74 0.1205
R1020 O_SENSE_CLK.n76 O_SENSE_CLK.n75 0.1205
R1021 O_SENSE_CLK.n77 O_SENSE_CLK.n76 0.1205
R1022 O_SENSE_CLK.n78 O_SENSE_CLK.n77 0.1205
R1023 O_SENSE_CLK.n79 O_SENSE_CLK.n78 0.1205
R1024 O_SENSE_CLK.n80 O_SENSE_CLK.n72 0.1205
R1025 O_SENSE_CLK.n81 O_SENSE_CLK.n80 0.1205
R1026 O_SENSE_CLK.n82 O_SENSE_CLK.n81 0.1205
R1027 O_SENSE_CLK.n83 O_SENSE_CLK.n82 0.1205
R1028 O_SENSE_CLK.n84 O_SENSE_CLK.n83 0.1205
R1029 O_SENSE_CLK.n85 O_SENSE_CLK.n84 0.1205
R1030 O_SENSE_CLK.n86 O_SENSE_CLK.n85 0.1205
R1031 O_SENSE_CLK.n87 O_SENSE_CLK.n86 0.1205
R1032 O_SENSE_CLK.n59 O_SENSE_CLK.n56 0.114816
R1033 O_SENSE_CLK.n41 O_SENSE_CLK.n35 0.1085
R1034 O_SENSE_CLK.n53 O_SENSE_CLK.n52 0.1085
R1035 O_SENSE_CLK.n33 O_SENSE_CLK.n32 0.0785
R1036 O_SENSE_CLK.n70 O_SENSE_CLK.n69 0.0785
R1037 O_SENSE_CLK.n63 O_SENSE_CLK.n56 0.0241842
R1038 E_SENSE_CLK.n58 E_SENSE_CLK.t4 139.702
R1039 E_SENSE_CLK.n56 E_SENSE_CLK.t0 135.246
R1040 E_SENSE_CLK.n61 E_SENSE_CLK.t1 135.246
R1041 E_SENSE_CLK.n60 E_SENSE_CLK.t2 135.246
R1042 E_SENSE_CLK.n59 E_SENSE_CLK.t3 135.246
R1043 E_SENSE_CLK.t14 E_SENSE_CLK.n80 127.788
R1044 E_SENSE_CLK.t19 E_SENSE_CLK.n42 127.788
R1045 E_SENSE_CLK.t31 E_SENSE_CLK.n15 127.788
R1046 E_SENSE_CLK.t26 E_SENSE_CLK.n35 127.776
R1047 E_SENSE_CLK.t5 E_SENSE_CLK.n72 127.668
R1048 E_SENSE_CLK.t6 E_SENSE_CLK.n95 127.668
R1049 E_SENSE_CLK.n94 E_SENSE_CLK.t7 127.668
R1050 E_SENSE_CLK.n93 E_SENSE_CLK.t8 127.668
R1051 E_SENSE_CLK.t9 E_SENSE_CLK.n75 127.668
R1052 E_SENSE_CLK.t10 E_SENSE_CLK.n87 127.668
R1053 E_SENSE_CLK.n86 E_SENSE_CLK.t11 127.668
R1054 E_SENSE_CLK.n85 E_SENSE_CLK.t12 127.668
R1055 E_SENSE_CLK.t13 E_SENSE_CLK.n80 127.668
R1056 E_SENSE_CLK.t24 E_SENSE_CLK.n49 127.668
R1057 E_SENSE_CLK.t25 E_SENSE_CLK.n35 127.668
R1058 E_SENSE_CLK.n42 E_SENSE_CLK.t20 127.668
R1059 E_SENSE_CLK.t21 E_SENSE_CLK.n38 127.668
R1060 E_SENSE_CLK.n47 E_SENSE_CLK.t22 127.668
R1061 E_SENSE_CLK.n48 E_SENSE_CLK.t23 127.668
R1062 E_SENSE_CLK.t40 E_SENSE_CLK.n0 127.668
R1063 E_SENSE_CLK.n15 E_SENSE_CLK.t32 127.668
R1064 E_SENSE_CLK.n14 E_SENSE_CLK.t33 127.668
R1065 E_SENSE_CLK.n13 E_SENSE_CLK.t34 127.668
R1066 E_SENSE_CLK.n12 E_SENSE_CLK.t35 127.668
R1067 E_SENSE_CLK.n11 E_SENSE_CLK.t36 127.668
R1068 E_SENSE_CLK.n10 E_SENSE_CLK.t37 127.668
R1069 E_SENSE_CLK.n9 E_SENSE_CLK.t38 127.668
R1070 E_SENSE_CLK.n8 E_SENSE_CLK.t39 127.668
R1071 E_SENSE_CLK.n66 E_SENSE_CLK.t15 113.632
R1072 E_SENSE_CLK.n82 E_SENSE_CLK.t14 113.632
R1073 E_SENSE_CLK.n29 E_SENSE_CLK.t27 113.632
R1074 E_SENSE_CLK.n43 E_SENSE_CLK.t19 113.632
R1075 E_SENSE_CLK.n16 E_SENSE_CLK.t31 113.632
R1076 E_SENSE_CLK.n52 E_SENSE_CLK.t26 113.629
R1077 E_SENSE_CLK.n68 E_SENSE_CLK.t17 109.174
R1078 E_SENSE_CLK.n69 E_SENSE_CLK.t18 109.174
R1079 E_SENSE_CLK.n67 E_SENSE_CLK.t16 109.174
R1080 E_SENSE_CLK.n97 E_SENSE_CLK.t5 109.174
R1081 E_SENSE_CLK.n96 E_SENSE_CLK.t6 109.174
R1082 E_SENSE_CLK.t7 E_SENSE_CLK.n74 109.174
R1083 E_SENSE_CLK.t8 E_SENSE_CLK.n92 109.174
R1084 E_SENSE_CLK.n76 E_SENSE_CLK.t9 109.174
R1085 E_SENSE_CLK.n88 E_SENSE_CLK.t10 109.174
R1086 E_SENSE_CLK.t11 E_SENSE_CLK.n79 109.174
R1087 E_SENSE_CLK.t12 E_SENSE_CLK.n84 109.174
R1088 E_SENSE_CLK.n81 E_SENSE_CLK.t13 109.174
R1089 E_SENSE_CLK.n31 E_SENSE_CLK.t29 109.174
R1090 E_SENSE_CLK.n32 E_SENSE_CLK.t30 109.174
R1091 E_SENSE_CLK.n30 E_SENSE_CLK.t28 109.174
R1092 E_SENSE_CLK.n50 E_SENSE_CLK.t24 109.174
R1093 E_SENSE_CLK.n51 E_SENSE_CLK.t25 109.174
R1094 E_SENSE_CLK.n44 E_SENSE_CLK.t20 109.174
R1095 E_SENSE_CLK.n45 E_SENSE_CLK.t21 109.174
R1096 E_SENSE_CLK.t22 E_SENSE_CLK.n46 109.174
R1097 E_SENSE_CLK.t23 E_SENSE_CLK.n37 109.174
R1098 E_SENSE_CLK.n25 E_SENSE_CLK.t40 109.174
R1099 E_SENSE_CLK.n17 E_SENSE_CLK.t32 109.174
R1100 E_SENSE_CLK.n18 E_SENSE_CLK.t33 109.174
R1101 E_SENSE_CLK.n19 E_SENSE_CLK.t34 109.174
R1102 E_SENSE_CLK.n20 E_SENSE_CLK.t35 109.174
R1103 E_SENSE_CLK.n21 E_SENSE_CLK.t36 109.174
R1104 E_SENSE_CLK.n22 E_SENSE_CLK.t37 109.174
R1105 E_SENSE_CLK.n23 E_SENSE_CLK.t38 109.174
R1106 E_SENSE_CLK.n24 E_SENSE_CLK.t39 109.174
R1107 E_SENSE_CLK.n71 E_SENSE_CLK.n70 24.5548
R1108 E_SENSE_CLK.n34 E_SENSE_CLK.n33 24.5548
R1109 E_SENSE_CLK.n34 E_SENSE_CLK.n27 20.0548
R1110 E_SENSE_CLK.n63 E_SENSE_CLK.n56 18.5723
R1111 E_SENSE_CLK.n70 E_SENSE_CLK.n69 18.5179
R1112 E_SENSE_CLK.n33 E_SENSE_CLK.n32 18.5179
R1113 E_SENSE_CLK.n62 E_SENSE_CLK.n61 18.4942
R1114 E_SENSE_CLK.n60 E_SENSE_CLK.n57 18.4942
R1115 E_SENSE_CLK.n68 E_SENSE_CLK.n65 18.4942
R1116 E_SENSE_CLK.n98 E_SENSE_CLK.n97 18.4942
R1117 E_SENSE_CLK.n96 E_SENSE_CLK.n73 18.4942
R1118 E_SENSE_CLK.n77 E_SENSE_CLK.n74 18.4942
R1119 E_SENSE_CLK.n92 E_SENSE_CLK.n91 18.4942
R1120 E_SENSE_CLK.n90 E_SENSE_CLK.n76 18.4942
R1121 E_SENSE_CLK.n89 E_SENSE_CLK.n88 18.4942
R1122 E_SENSE_CLK.n79 E_SENSE_CLK.n78 18.4942
R1123 E_SENSE_CLK.n84 E_SENSE_CLK.n83 18.4942
R1124 E_SENSE_CLK.n31 E_SENSE_CLK.n28 18.4942
R1125 E_SENSE_CLK.n50 E_SENSE_CLK.n36 18.4942
R1126 E_SENSE_CLK.n45 E_SENSE_CLK.n41 18.4942
R1127 E_SENSE_CLK.n46 E_SENSE_CLK.n40 18.4942
R1128 E_SENSE_CLK.n39 E_SENSE_CLK.n37 18.4942
R1129 E_SENSE_CLK.n26 E_SENSE_CLK.n25 18.4942
R1130 E_SENSE_CLK.n18 E_SENSE_CLK.n7 18.4942
R1131 E_SENSE_CLK.n19 E_SENSE_CLK.n6 18.4942
R1132 E_SENSE_CLK.n20 E_SENSE_CLK.n5 18.4942
R1133 E_SENSE_CLK.n21 E_SENSE_CLK.n4 18.4942
R1134 E_SENSE_CLK.n22 E_SENSE_CLK.n3 18.4942
R1135 E_SENSE_CLK.n23 E_SENSE_CLK.n2 18.4942
R1136 E_SENSE_CLK.n24 E_SENSE_CLK.n1 18.4942
R1137 E_SENSE_CLK.n100 E_SENSE_CLK.n99 15.5548
R1138 E_SENSE_CLK.n55 E_SENSE_CLK.n54 15.5548
R1139 E_SENSE_CLK.n64 E_SENSE_CLK.n63 14.5766
R1140 E_SENSE_CLK E_SENSE_CLK.n100 13.9118
R1141 E_SENSE_CLK.n61 E_SENSE_CLK.n56 11.6805
R1142 E_SENSE_CLK.n61 E_SENSE_CLK.n60 11.6805
R1143 E_SENSE_CLK.n60 E_SENSE_CLK.n59 11.6805
R1144 E_SENSE_CLK.n68 E_SENSE_CLK.n67 11.6805
R1145 E_SENSE_CLK.n69 E_SENSE_CLK.n68 11.6805
R1146 E_SENSE_CLK.n97 E_SENSE_CLK.n96 11.6805
R1147 E_SENSE_CLK.n96 E_SENSE_CLK.n74 11.6805
R1148 E_SENSE_CLK.n92 E_SENSE_CLK.n74 11.6805
R1149 E_SENSE_CLK.n92 E_SENSE_CLK.n76 11.6805
R1150 E_SENSE_CLK.n88 E_SENSE_CLK.n76 11.6805
R1151 E_SENSE_CLK.n88 E_SENSE_CLK.n79 11.6805
R1152 E_SENSE_CLK.n84 E_SENSE_CLK.n79 11.6805
R1153 E_SENSE_CLK.n84 E_SENSE_CLK.n81 11.6805
R1154 E_SENSE_CLK.n31 E_SENSE_CLK.n30 11.6805
R1155 E_SENSE_CLK.n32 E_SENSE_CLK.n31 11.6805
R1156 E_SENSE_CLK.n51 E_SENSE_CLK.n50 11.6805
R1157 E_SENSE_CLK.n45 E_SENSE_CLK.n44 11.6805
R1158 E_SENSE_CLK.n46 E_SENSE_CLK.n45 11.6805
R1159 E_SENSE_CLK.n46 E_SENSE_CLK.n37 11.6805
R1160 E_SENSE_CLK.n50 E_SENSE_CLK.n37 11.6805
R1161 E_SENSE_CLK.n18 E_SENSE_CLK.n17 11.6805
R1162 E_SENSE_CLK.n19 E_SENSE_CLK.n18 11.6805
R1163 E_SENSE_CLK.n20 E_SENSE_CLK.n19 11.6805
R1164 E_SENSE_CLK.n21 E_SENSE_CLK.n20 11.6805
R1165 E_SENSE_CLK.n22 E_SENSE_CLK.n21 11.6805
R1166 E_SENSE_CLK.n23 E_SENSE_CLK.n22 11.6805
R1167 E_SENSE_CLK.n24 E_SENSE_CLK.n23 11.6805
R1168 E_SENSE_CLK.n25 E_SENSE_CLK.n24 11.6805
R1169 E_SENSE_CLK.n27 E_SENSE_CLK.n0 11.1876
R1170 E_SENSE_CLK.n99 E_SENSE_CLK.n72 11.0376
R1171 E_SENSE_CLK.n54 E_SENSE_CLK.n35 10.8396
R1172 E_SENSE_CLK.n27 E_SENSE_CLK.n26 9.3485
R1173 E_SENSE_CLK.n99 E_SENSE_CLK.n98 9.1985
R1174 E_SENSE_CLK.n54 E_SENSE_CLK.n53 9.0005
R1175 E_SENSE_CLK.n58 E_SENSE_CLK.n57 7.17687
R1176 E_SENSE_CLK.n66 E_SENSE_CLK.n65 7.17687
R1177 E_SENSE_CLK.n83 E_SENSE_CLK.n82 7.17687
R1178 E_SENSE_CLK.n29 E_SENSE_CLK.n28 7.17687
R1179 E_SENSE_CLK.n43 E_SENSE_CLK.n41 7.17687
R1180 E_SENSE_CLK.n16 E_SENSE_CLK.n7 7.17687
R1181 E_SENSE_CLK.n53 E_SENSE_CLK.n52 7.05405
R1182 E_SENSE_CLK.n100 E_SENSE_CLK.n71 4.69615
R1183 E_SENSE_CLK.n52 E_SENSE_CLK.n51 4.4296
R1184 E_SENSE_CLK.n59 E_SENSE_CLK.n58 4.42851
R1185 E_SENSE_CLK.n67 E_SENSE_CLK.n66 4.42851
R1186 E_SENSE_CLK.n82 E_SENSE_CLK.n81 4.42851
R1187 E_SENSE_CLK.n30 E_SENSE_CLK.n29 4.42851
R1188 E_SENSE_CLK.n44 E_SENSE_CLK.n43 4.42851
R1189 E_SENSE_CLK.n17 E_SENSE_CLK.n16 4.42851
R1190 E_SENSE_CLK.n55 E_SENSE_CLK.n34 3.32659
R1191 E_SENSE_CLK.n71 E_SENSE_CLK.n64 2.73963
R1192 E_SENSE_CLK.n64 E_SENSE_CLK.n55 0.978761
R1193 E_SENSE_CLK.n83 E_SENSE_CLK.n78 0.1205
R1194 E_SENSE_CLK.n89 E_SENSE_CLK.n78 0.1205
R1195 E_SENSE_CLK.n90 E_SENSE_CLK.n89 0.1205
R1196 E_SENSE_CLK.n91 E_SENSE_CLK.n90 0.1205
R1197 E_SENSE_CLK.n91 E_SENSE_CLK.n77 0.1205
R1198 E_SENSE_CLK.n77 E_SENSE_CLK.n73 0.1205
R1199 E_SENSE_CLK.n98 E_SENSE_CLK.n73 0.1205
R1200 E_SENSE_CLK.n85 E_SENSE_CLK.n80 0.1205
R1201 E_SENSE_CLK.n86 E_SENSE_CLK.n85 0.1205
R1202 E_SENSE_CLK.n87 E_SENSE_CLK.n86 0.1205
R1203 E_SENSE_CLK.n87 E_SENSE_CLK.n75 0.1205
R1204 E_SENSE_CLK.n93 E_SENSE_CLK.n75 0.1205
R1205 E_SENSE_CLK.n94 E_SENSE_CLK.n93 0.1205
R1206 E_SENSE_CLK.n95 E_SENSE_CLK.n94 0.1205
R1207 E_SENSE_CLK.n95 E_SENSE_CLK.n72 0.1205
R1208 E_SENSE_CLK.n39 E_SENSE_CLK.n36 0.1205
R1209 E_SENSE_CLK.n40 E_SENSE_CLK.n39 0.1205
R1210 E_SENSE_CLK.n41 E_SENSE_CLK.n40 0.1205
R1211 E_SENSE_CLK.n49 E_SENSE_CLK.n48 0.1205
R1212 E_SENSE_CLK.n48 E_SENSE_CLK.n47 0.1205
R1213 E_SENSE_CLK.n47 E_SENSE_CLK.n38 0.1205
R1214 E_SENSE_CLK.n42 E_SENSE_CLK.n38 0.1205
R1215 E_SENSE_CLK.n26 E_SENSE_CLK.n1 0.1205
R1216 E_SENSE_CLK.n2 E_SENSE_CLK.n1 0.1205
R1217 E_SENSE_CLK.n3 E_SENSE_CLK.n2 0.1205
R1218 E_SENSE_CLK.n4 E_SENSE_CLK.n3 0.1205
R1219 E_SENSE_CLK.n5 E_SENSE_CLK.n4 0.1205
R1220 E_SENSE_CLK.n6 E_SENSE_CLK.n5 0.1205
R1221 E_SENSE_CLK.n7 E_SENSE_CLK.n6 0.1205
R1222 E_SENSE_CLK.n8 E_SENSE_CLK.n0 0.1205
R1223 E_SENSE_CLK.n9 E_SENSE_CLK.n8 0.1205
R1224 E_SENSE_CLK.n10 E_SENSE_CLK.n9 0.1205
R1225 E_SENSE_CLK.n11 E_SENSE_CLK.n10 0.1205
R1226 E_SENSE_CLK.n12 E_SENSE_CLK.n11 0.1205
R1227 E_SENSE_CLK.n13 E_SENSE_CLK.n12 0.1205
R1228 E_SENSE_CLK.n14 E_SENSE_CLK.n13 0.1205
R1229 E_SENSE_CLK.n15 E_SENSE_CLK.n14 0.1205
R1230 E_SENSE_CLK.n62 E_SENSE_CLK.n57 0.114816
R1231 E_SENSE_CLK.n53 E_SENSE_CLK.n36 0.1085
R1232 E_SENSE_CLK.n49 E_SENSE_CLK.n35 0.1085
R1233 E_SENSE_CLK.n70 E_SENSE_CLK.n65 0.0785
R1234 E_SENSE_CLK.n33 E_SENSE_CLK.n28 0.0785
R1235 E_SENSE_CLK.n63 E_SENSE_CLK.n62 0.0241842
R1236 O_CAPTURE_CLK.n14 O_CAPTURE_CLK.t8 113.632
R1237 O_CAPTURE_CLK.n18 O_CAPTURE_CLK.t15 113.632
R1238 O_CAPTURE_CLK.n5 O_CAPTURE_CLK.t7 113.632
R1239 O_CAPTURE_CLK.n23 O_CAPTURE_CLK.t9 109.174
R1240 O_CAPTURE_CLK.n24 O_CAPTURE_CLK.t10 109.174
R1241 O_CAPTURE_CLK.n22 O_CAPTURE_CLK.t11 109.174
R1242 O_CAPTURE_CLK.n21 O_CAPTURE_CLK.t12 109.174
R1243 O_CAPTURE_CLK.n16 O_CAPTURE_CLK.t13 109.174
R1244 O_CAPTURE_CLK.n17 O_CAPTURE_CLK.t14 109.174
R1245 O_CAPTURE_CLK.n0 O_CAPTURE_CLK.t0 109.174
R1246 O_CAPTURE_CLK.n11 O_CAPTURE_CLK.t1 109.174
R1247 O_CAPTURE_CLK.n6 O_CAPTURE_CLK.t6 109.174
R1248 O_CAPTURE_CLK.n7 O_CAPTURE_CLK.t5 109.174
R1249 O_CAPTURE_CLK.n8 O_CAPTURE_CLK.t4 109.174
R1250 O_CAPTURE_CLK.n9 O_CAPTURE_CLK.t3 109.174
R1251 O_CAPTURE_CLK.n10 O_CAPTURE_CLK.t2 109.174
R1252 O_CAPTURE_CLK.n27 O_CAPTURE_CLK.n13 19.4679
R1253 O_CAPTURE_CLK O_CAPTURE_CLK.n27 18.7296
R1254 O_CAPTURE_CLK.n13 O_CAPTURE_CLK.n0 18.5636
R1255 O_CAPTURE_CLK.n25 O_CAPTURE_CLK.n24 18.4942
R1256 O_CAPTURE_CLK.n22 O_CAPTURE_CLK.n15 18.4942
R1257 O_CAPTURE_CLK.n21 O_CAPTURE_CLK.n20 18.4942
R1258 O_CAPTURE_CLK.n19 O_CAPTURE_CLK.n16 18.4942
R1259 O_CAPTURE_CLK.n12 O_CAPTURE_CLK.n11 18.4942
R1260 O_CAPTURE_CLK.n7 O_CAPTURE_CLK.n4 18.4942
R1261 O_CAPTURE_CLK.n8 O_CAPTURE_CLK.n3 18.4942
R1262 O_CAPTURE_CLK.n9 O_CAPTURE_CLK.n2 18.4942
R1263 O_CAPTURE_CLK.n10 O_CAPTURE_CLK.n1 18.4942
R1264 O_CAPTURE_CLK.n27 O_CAPTURE_CLK.n26 14.9288
R1265 O_CAPTURE_CLK.n24 O_CAPTURE_CLK.n23 11.6805
R1266 O_CAPTURE_CLK.n24 O_CAPTURE_CLK.n22 11.6805
R1267 O_CAPTURE_CLK.n22 O_CAPTURE_CLK.n21 11.6805
R1268 O_CAPTURE_CLK.n21 O_CAPTURE_CLK.n16 11.6805
R1269 O_CAPTURE_CLK.n17 O_CAPTURE_CLK.n16 11.6805
R1270 O_CAPTURE_CLK.n11 O_CAPTURE_CLK.n0 11.6805
R1271 O_CAPTURE_CLK.n7 O_CAPTURE_CLK.n6 11.6805
R1272 O_CAPTURE_CLK.n8 O_CAPTURE_CLK.n7 11.6805
R1273 O_CAPTURE_CLK.n9 O_CAPTURE_CLK.n8 11.6805
R1274 O_CAPTURE_CLK.n10 O_CAPTURE_CLK.n9 11.6805
R1275 O_CAPTURE_CLK.n11 O_CAPTURE_CLK.n10 11.6805
R1276 O_CAPTURE_CLK.n19 O_CAPTURE_CLK.n18 7.17687
R1277 O_CAPTURE_CLK.n5 O_CAPTURE_CLK.n4 7.17687
R1278 O_CAPTURE_CLK.n26 O_CAPTURE_CLK.n14 7.10487
R1279 O_CAPTURE_CLK.n23 O_CAPTURE_CLK.n14 4.42851
R1280 O_CAPTURE_CLK.n18 O_CAPTURE_CLK.n17 4.42851
R1281 O_CAPTURE_CLK.n6 O_CAPTURE_CLK.n5 4.42851
R1282 O_CAPTURE_CLK.n20 O_CAPTURE_CLK.n19 0.1205
R1283 O_CAPTURE_CLK.n20 O_CAPTURE_CLK.n15 0.1205
R1284 O_CAPTURE_CLK.n25 O_CAPTURE_CLK.n15 0.1205
R1285 O_CAPTURE_CLK.n4 O_CAPTURE_CLK.n3 0.1205
R1286 O_CAPTURE_CLK.n3 O_CAPTURE_CLK.n2 0.1205
R1287 O_CAPTURE_CLK.n2 O_CAPTURE_CLK.n1 0.1205
R1288 O_CAPTURE_CLK.n12 O_CAPTURE_CLK.n1 0.1205
R1289 O_CAPTURE_CLK.n26 O_CAPTURE_CLK.n25 0.0485
R1290 O_CAPTURE_CLK.n13 O_CAPTURE_CLK.n12 0.0485
R1291 E_CAPTURE_CLK.n5 E_CAPTURE_CLK.t7 113.632
R1292 E_CAPTURE_CLK.n14 E_CAPTURE_CLK.t8 113.632
R1293 E_CAPTURE_CLK.n18 E_CAPTURE_CLK.t15 113.632
R1294 E_CAPTURE_CLK.n0 E_CAPTURE_CLK.t0 109.174
R1295 E_CAPTURE_CLK.n11 E_CAPTURE_CLK.t1 109.174
R1296 E_CAPTURE_CLK.n6 E_CAPTURE_CLK.t6 109.174
R1297 E_CAPTURE_CLK.n7 E_CAPTURE_CLK.t5 109.174
R1298 E_CAPTURE_CLK.n8 E_CAPTURE_CLK.t4 109.174
R1299 E_CAPTURE_CLK.n9 E_CAPTURE_CLK.t3 109.174
R1300 E_CAPTURE_CLK.n10 E_CAPTURE_CLK.t2 109.174
R1301 E_CAPTURE_CLK.n23 E_CAPTURE_CLK.t9 109.174
R1302 E_CAPTURE_CLK.n24 E_CAPTURE_CLK.t10 109.174
R1303 E_CAPTURE_CLK.n22 E_CAPTURE_CLK.t11 109.174
R1304 E_CAPTURE_CLK.n21 E_CAPTURE_CLK.t12 109.174
R1305 E_CAPTURE_CLK.n16 E_CAPTURE_CLK.t13 109.174
R1306 E_CAPTURE_CLK.n17 E_CAPTURE_CLK.t14 109.174
R1307 E_CAPTURE_CLK E_CAPTURE_CLK.n27 19.486
R1308 E_CAPTURE_CLK.n13 E_CAPTURE_CLK.n0 18.5636
R1309 E_CAPTURE_CLK.n12 E_CAPTURE_CLK.n11 18.4942
R1310 E_CAPTURE_CLK.n7 E_CAPTURE_CLK.n4 18.4942
R1311 E_CAPTURE_CLK.n8 E_CAPTURE_CLK.n3 18.4942
R1312 E_CAPTURE_CLK.n9 E_CAPTURE_CLK.n2 18.4942
R1313 E_CAPTURE_CLK.n10 E_CAPTURE_CLK.n1 18.4942
R1314 E_CAPTURE_CLK.n25 E_CAPTURE_CLK.n24 18.4942
R1315 E_CAPTURE_CLK.n22 E_CAPTURE_CLK.n15 18.4942
R1316 E_CAPTURE_CLK.n21 E_CAPTURE_CLK.n20 18.4942
R1317 E_CAPTURE_CLK.n19 E_CAPTURE_CLK.n16 18.4942
R1318 E_CAPTURE_CLK.n27 E_CAPTURE_CLK.n13 18.4114
R1319 E_CAPTURE_CLK.n27 E_CAPTURE_CLK.n26 13.5592
R1320 E_CAPTURE_CLK.n11 E_CAPTURE_CLK.n0 11.6805
R1321 E_CAPTURE_CLK.n7 E_CAPTURE_CLK.n6 11.6805
R1322 E_CAPTURE_CLK.n8 E_CAPTURE_CLK.n7 11.6805
R1323 E_CAPTURE_CLK.n9 E_CAPTURE_CLK.n8 11.6805
R1324 E_CAPTURE_CLK.n10 E_CAPTURE_CLK.n9 11.6805
R1325 E_CAPTURE_CLK.n11 E_CAPTURE_CLK.n10 11.6805
R1326 E_CAPTURE_CLK.n24 E_CAPTURE_CLK.n23 11.6805
R1327 E_CAPTURE_CLK.n24 E_CAPTURE_CLK.n22 11.6805
R1328 E_CAPTURE_CLK.n22 E_CAPTURE_CLK.n21 11.6805
R1329 E_CAPTURE_CLK.n21 E_CAPTURE_CLK.n16 11.6805
R1330 E_CAPTURE_CLK.n17 E_CAPTURE_CLK.n16 11.6805
R1331 E_CAPTURE_CLK.n5 E_CAPTURE_CLK.n4 7.17687
R1332 E_CAPTURE_CLK.n19 E_CAPTURE_CLK.n18 7.17687
R1333 E_CAPTURE_CLK.n26 E_CAPTURE_CLK.n14 7.10487
R1334 E_CAPTURE_CLK.n6 E_CAPTURE_CLK.n5 4.42851
R1335 E_CAPTURE_CLK.n23 E_CAPTURE_CLK.n14 4.42851
R1336 E_CAPTURE_CLK.n18 E_CAPTURE_CLK.n17 4.42851
R1337 E_CAPTURE_CLK.n4 E_CAPTURE_CLK.n3 0.1205
R1338 E_CAPTURE_CLK.n3 E_CAPTURE_CLK.n2 0.1205
R1339 E_CAPTURE_CLK.n2 E_CAPTURE_CLK.n1 0.1205
R1340 E_CAPTURE_CLK.n12 E_CAPTURE_CLK.n1 0.1205
R1341 E_CAPTURE_CLK.n20 E_CAPTURE_CLK.n19 0.1205
R1342 E_CAPTURE_CLK.n20 E_CAPTURE_CLK.n15 0.1205
R1343 E_CAPTURE_CLK.n25 E_CAPTURE_CLK.n15 0.1205
R1344 E_CAPTURE_CLK.n13 E_CAPTURE_CLK.n12 0.0485
R1345 E_CAPTURE_CLK.n26 E_CAPTURE_CLK.n25 0.0485
R1346 FE_O_N.n16 FE_O_N.t10 113.632
R1347 FE_O_N.n13 FE_O_N.t7 113.632
R1348 FE_O_N.n6 FE_O_N.t11 113.632
R1349 FE_O_N.n2 FE_O_N.t18 113.632
R1350 FE_O_N.n14 FE_O_N.t8 109.174
R1351 FE_O_N.n15 FE_O_N.t9 109.174
R1352 FE_O_N.n7 FE_O_N.t12 109.174
R1353 FE_O_N.n8 FE_O_N.t13 109.174
R1354 FE_O_N.n9 FE_O_N.t14 109.174
R1355 FE_O_N.n10 FE_O_N.t15 109.174
R1356 FE_O_N.n4 FE_O_N.t16 109.174
R1357 FE_O_N.n3 FE_O_N.t17 109.174
R1358 FE_O_N.n25 FE_O_N.n18 74.8513
R1359 FE_O_N.n8 FE_O_N.n5 18.4942
R1360 FE_O_N.n9 FE_O_N.n0 18.4942
R1361 FE_O_N.n11 FE_O_N.n10 18.4942
R1362 FE_O_N.n4 FE_O_N.n1 18.4942
R1363 FE_O_N.n18 FE_O_N.n12 14.8701
R1364 FE_O_N.n15 FE_O_N.n14 11.6805
R1365 FE_O_N.n8 FE_O_N.n7 11.6805
R1366 FE_O_N.n9 FE_O_N.n8 11.6805
R1367 FE_O_N.n10 FE_O_N.n9 11.6805
R1368 FE_O_N.n10 FE_O_N.n4 11.6805
R1369 FE_O_N.n4 FE_O_N.n3 11.6805
R1370 FE_O_N.n24 FE_O_N.n21 10.957
R1371 FE_O_N.n24 FE_O_N.n23 10.5657
R1372 FE_O_N.n18 FE_O_N.n17 9.0005
R1373 FE_O_N.n25 FE_O_N.n24 8.57007
R1374 FE_O_N.n6 FE_O_N.n5 7.17687
R1375 FE_O_N.n2 FE_O_N.n1 7.17687
R1376 FE_O_N.n17 FE_O_N.n13 7.10487
R1377 FE_O_N.n17 FE_O_N.n16 7.10487
R1378 FE_O_N.n20 FE_O_N.t3 5.7796
R1379 FE_O_N.n23 FE_O_N.t6 5.71396
R1380 FE_O_N.n21 FE_O_N.t1 5.68486
R1381 FE_O_N.n20 FE_O_N.n19 5.38537
R1382 FE_O_N.n23 FE_O_N.n22 5.34435
R1383 FE_O_N.n14 FE_O_N.n13 4.42851
R1384 FE_O_N.n16 FE_O_N.n15 4.42851
R1385 FE_O_N.n7 FE_O_N.n6 4.42851
R1386 FE_O_N.n3 FE_O_N.n2 4.42851
R1387 FE_O_N.n22 FE_O_N.t5 0.228
R1388 FE_O_N.n22 FE_O_N.t2 0.228
R1389 FE_O_N.n19 FE_O_N.t0 0.20525
R1390 FE_O_N.n19 FE_O_N.t4 0.20525
R1391 FE_O_N.n5 FE_O_N.n0 0.1205
R1392 FE_O_N.n11 FE_O_N.n1 0.1205
R1393 FE_O_N.n21 FE_O_N.n20 0.0952368
R1394 FE_O_N.n12 FE_O_N.n0 0.0485
R1395 FE_O_N.n12 FE_O_N.n11 0.0485
R1396 FE_O_N FE_O_N.n25 0.0205
R1397 FE_O_P.n16 FE_O_P.t10 113.632
R1398 FE_O_P.n13 FE_O_P.t7 113.632
R1399 FE_O_P.n6 FE_O_P.t11 113.632
R1400 FE_O_P.n2 FE_O_P.t18 113.632
R1401 FE_O_P.n14 FE_O_P.t8 109.174
R1402 FE_O_P.n15 FE_O_P.t9 109.174
R1403 FE_O_P.n7 FE_O_P.t12 109.174
R1404 FE_O_P.n8 FE_O_P.t13 109.174
R1405 FE_O_P.n9 FE_O_P.t14 109.174
R1406 FE_O_P.n10 FE_O_P.t15 109.174
R1407 FE_O_P.n4 FE_O_P.t16 109.174
R1408 FE_O_P.n3 FE_O_P.t17 109.174
R1409 FE_O_P FE_O_P.n18 76.9565
R1410 FE_O_P.n8 FE_O_P.n5 18.4942
R1411 FE_O_P.n9 FE_O_P.n0 18.4942
R1412 FE_O_P.n11 FE_O_P.n10 18.4942
R1413 FE_O_P.n4 FE_O_P.n1 18.4942
R1414 FE_O_P.n18 FE_O_P.n12 14.8701
R1415 FE_O_P.n15 FE_O_P.n14 11.6805
R1416 FE_O_P.n8 FE_O_P.n7 11.6805
R1417 FE_O_P.n9 FE_O_P.n8 11.6805
R1418 FE_O_P.n10 FE_O_P.n9 11.6805
R1419 FE_O_P.n10 FE_O_P.n4 11.6805
R1420 FE_O_P.n4 FE_O_P.n3 11.6805
R1421 FE_O_P.n24 FE_O_P.n20 11.0353
R1422 FE_O_P.n24 FE_O_P.n23 10.4875
R1423 FE_O_P.n18 FE_O_P.n17 9.0005
R1424 FE_O_P FE_O_P.n24 8.47267
R1425 FE_O_P.n6 FE_O_P.n5 7.17687
R1426 FE_O_P.n2 FE_O_P.n1 7.17687
R1427 FE_O_P.n17 FE_O_P.n13 7.10487
R1428 FE_O_P.n17 FE_O_P.n16 7.10487
R1429 FE_O_P.n22 FE_O_P.t5 5.7796
R1430 FE_O_P.n20 FE_O_P.t1 5.71396
R1431 FE_O_P.n23 FE_O_P.t4 5.68486
R1432 FE_O_P.n22 FE_O_P.n21 5.38537
R1433 FE_O_P.n20 FE_O_P.n19 5.34435
R1434 FE_O_P.n14 FE_O_P.n13 4.42851
R1435 FE_O_P.n16 FE_O_P.n15 4.42851
R1436 FE_O_P.n7 FE_O_P.n6 4.42851
R1437 FE_O_P.n3 FE_O_P.n2 4.42851
R1438 FE_O_P.n19 FE_O_P.t0 0.228
R1439 FE_O_P.n19 FE_O_P.t6 0.228
R1440 FE_O_P.n21 FE_O_P.t3 0.20525
R1441 FE_O_P.n21 FE_O_P.t2 0.20525
R1442 FE_O_P.n5 FE_O_P.n0 0.1205
R1443 FE_O_P.n11 FE_O_P.n1 0.1205
R1444 FE_O_P.n23 FE_O_P.n22 0.0952368
R1445 FE_O_P.n12 FE_O_P.n0 0.0485
R1446 FE_O_P.n12 FE_O_P.n11 0.0485
R1447 FE_E_P.n16 FE_E_P.t10 113.632
R1448 FE_E_P.n13 FE_E_P.t7 113.632
R1449 FE_E_P.n6 FE_E_P.t11 113.632
R1450 FE_E_P.n2 FE_E_P.t18 113.632
R1451 FE_E_P.n14 FE_E_P.t8 109.174
R1452 FE_E_P.n15 FE_E_P.t9 109.174
R1453 FE_E_P.n7 FE_E_P.t12 109.174
R1454 FE_E_P.n8 FE_E_P.t13 109.174
R1455 FE_E_P.n9 FE_E_P.t14 109.174
R1456 FE_E_P.n10 FE_E_P.t15 109.174
R1457 FE_E_P.n4 FE_E_P.t16 109.174
R1458 FE_E_P.n3 FE_E_P.t17 109.174
R1459 FE_E_P FE_E_P.n18 77.1792
R1460 FE_E_P.n8 FE_E_P.n5 18.4942
R1461 FE_E_P.n9 FE_E_P.n0 18.4942
R1462 FE_E_P.n11 FE_E_P.n10 18.4942
R1463 FE_E_P.n4 FE_E_P.n1 18.4942
R1464 FE_E_P.n18 FE_E_P.n12 14.8701
R1465 FE_E_P.n15 FE_E_P.n14 11.6805
R1466 FE_E_P.n8 FE_E_P.n7 11.6805
R1467 FE_E_P.n9 FE_E_P.n8 11.6805
R1468 FE_E_P.n10 FE_E_P.n9 11.6805
R1469 FE_E_P.n10 FE_E_P.n4 11.6805
R1470 FE_E_P.n4 FE_E_P.n3 11.6805
R1471 FE_E_P.n24 FE_E_P.n21 10.957
R1472 FE_E_P.n24 FE_E_P.n23 10.5657
R1473 FE_E_P.n18 FE_E_P.n17 9.0005
R1474 FE_E_P FE_E_P.n24 8.59007
R1475 FE_E_P.n6 FE_E_P.n5 7.17687
R1476 FE_E_P.n2 FE_E_P.n1 7.17687
R1477 FE_E_P.n17 FE_E_P.n13 7.10487
R1478 FE_E_P.n17 FE_E_P.n16 7.10487
R1479 FE_E_P.n20 FE_E_P.t1 5.7796
R1480 FE_E_P.n23 FE_E_P.t5 5.71396
R1481 FE_E_P.n21 FE_E_P.t3 5.68486
R1482 FE_E_P.n20 FE_E_P.n19 5.38537
R1483 FE_E_P.n23 FE_E_P.n22 5.34435
R1484 FE_E_P.n14 FE_E_P.n13 4.42851
R1485 FE_E_P.n16 FE_E_P.n15 4.42851
R1486 FE_E_P.n7 FE_E_P.n6 4.42851
R1487 FE_E_P.n3 FE_E_P.n2 4.42851
R1488 FE_E_P.n22 FE_E_P.t2 0.228
R1489 FE_E_P.n22 FE_E_P.t6 0.228
R1490 FE_E_P.n19 FE_E_P.t0 0.20525
R1491 FE_E_P.n19 FE_E_P.t4 0.20525
R1492 FE_E_P.n5 FE_E_P.n0 0.1205
R1493 FE_E_P.n11 FE_E_P.n1 0.1205
R1494 FE_E_P.n21 FE_E_P.n20 0.0952368
R1495 FE_E_P.n12 FE_E_P.n0 0.0485
R1496 FE_E_P.n12 FE_E_P.n11 0.0485
R1497 FE_E_N.n16 FE_E_N.t10 113.632
R1498 FE_E_N.n13 FE_E_N.t7 113.632
R1499 FE_E_N.n6 FE_E_N.t11 113.632
R1500 FE_E_N.n2 FE_E_N.t18 113.632
R1501 FE_E_N.n14 FE_E_N.t8 109.174
R1502 FE_E_N.n15 FE_E_N.t9 109.174
R1503 FE_E_N.n7 FE_E_N.t12 109.174
R1504 FE_E_N.n8 FE_E_N.t13 109.174
R1505 FE_E_N.n9 FE_E_N.t14 109.174
R1506 FE_E_N.n10 FE_E_N.t15 109.174
R1507 FE_E_N.n4 FE_E_N.t16 109.174
R1508 FE_E_N.n3 FE_E_N.t17 109.174
R1509 FE_E_N.n25 FE_E_N.n18 74.6287
R1510 FE_E_N.n8 FE_E_N.n5 18.4942
R1511 FE_E_N.n9 FE_E_N.n0 18.4942
R1512 FE_E_N.n11 FE_E_N.n10 18.4942
R1513 FE_E_N.n4 FE_E_N.n1 18.4942
R1514 FE_E_N.n18 FE_E_N.n12 14.8701
R1515 FE_E_N.n15 FE_E_N.n14 11.6805
R1516 FE_E_N.n8 FE_E_N.n7 11.6805
R1517 FE_E_N.n9 FE_E_N.n8 11.6805
R1518 FE_E_N.n10 FE_E_N.n9 11.6805
R1519 FE_E_N.n10 FE_E_N.n4 11.6805
R1520 FE_E_N.n4 FE_E_N.n3 11.6805
R1521 FE_E_N.n24 FE_E_N.n20 11.0353
R1522 FE_E_N.n24 FE_E_N.n23 10.4875
R1523 FE_E_N.n18 FE_E_N.n17 9.0005
R1524 FE_E_N.n25 FE_E_N.n24 8.45267
R1525 FE_E_N.n6 FE_E_N.n5 7.17687
R1526 FE_E_N.n2 FE_E_N.n1 7.17687
R1527 FE_E_N.n17 FE_E_N.n13 7.10487
R1528 FE_E_N.n17 FE_E_N.n16 7.10487
R1529 FE_E_N.n22 FE_E_N.t0 5.7796
R1530 FE_E_N.n20 FE_E_N.t1 5.71396
R1531 FE_E_N.n23 FE_E_N.t3 5.68486
R1532 FE_E_N.n22 FE_E_N.n21 5.38537
R1533 FE_E_N.n20 FE_E_N.n19 5.34435
R1534 FE_E_N.n14 FE_E_N.n13 4.42851
R1535 FE_E_N.n16 FE_E_N.n15 4.42851
R1536 FE_E_N.n7 FE_E_N.n6 4.42851
R1537 FE_E_N.n3 FE_E_N.n2 4.42851
R1538 FE_E_N.n19 FE_E_N.t6 0.228
R1539 FE_E_N.n19 FE_E_N.t2 0.228
R1540 FE_E_N.n21 FE_E_N.t5 0.20525
R1541 FE_E_N.n21 FE_E_N.t4 0.20525
R1542 FE_E_N.n5 FE_E_N.n0 0.1205
R1543 FE_E_N.n11 FE_E_N.n1 0.1205
R1544 FE_E_N.n23 FE_E_N.n22 0.0952368
R1545 FE_E_N.n12 FE_E_N.n0 0.0485
R1546 FE_E_N.n12 FE_E_N.n11 0.0485
R1547 FE_E_N FE_E_N.n25 0.0205
R1548 ODD_Q.n5 ODD_Q.n2 12.9918
R1549 ODD_Q ODD_Q.n5 10.5466
R1550 ODD_Q.n1 ODD_Q.t3 5.73764
R1551 ODD_Q.n2 ODD_Q.t1 5.6429
R1552 ODD_Q.n4 ODD_Q.t2 5.63749
R1553 ODD_Q.n4 ODD_Q.n3 5.52748
R1554 ODD_Q.n1 ODD_Q.n0 5.32067
R1555 ODD_Q.n5 ODD_Q.n4 4.61789
R1556 ODD_Q.n0 ODD_Q.t5 0.228
R1557 ODD_Q.n0 ODD_Q.t6 0.228
R1558 ODD_Q.n3 ODD_Q.t0 0.20525
R1559 ODD_Q.n3 ODD_Q.t4 0.20525
R1560 ODD_Q.n2 ODD_Q.n1 0.0952368
R1561 ODD_QB ODD_QB.n5 21.5031
R1562 ODD_QB.n5 ODD_QB.n2 12.7179
R1563 ODD_QB.n1 ODD_QB.t6 5.73764
R1564 ODD_QB.n2 ODD_QB.t0 5.6429
R1565 ODD_QB.n4 ODD_QB.t4 5.63749
R1566 ODD_QB.n4 ODD_QB.n3 5.52748
R1567 ODD_QB.n1 ODD_QB.n0 5.32067
R1568 ODD_QB.n5 ODD_QB.n4 4.8918
R1569 ODD_QB.n0 ODD_QB.t1 0.228
R1570 ODD_QB.n0 ODD_QB.t3 0.228
R1571 ODD_QB.n3 ODD_QB.t5 0.20525
R1572 ODD_QB.n3 ODD_QB.t2 0.20525
R1573 ODD_QB.n2 ODD_QB.n1 0.0952368
R1574 EVEN_QB EVEN_QB.n5 20.9553
R1575 EVEN_QB.n5 EVEN_QB.n2 13.1092
R1576 EVEN_QB.n1 EVEN_QB.t0 5.73764
R1577 EVEN_QB.n2 EVEN_QB.t5 5.6429
R1578 EVEN_QB.n4 EVEN_QB.t3 5.63749
R1579 EVEN_QB.n4 EVEN_QB.n3 5.52748
R1580 EVEN_QB.n1 EVEN_QB.n0 5.32067
R1581 EVEN_QB.n5 EVEN_QB.n4 4.5005
R1582 EVEN_QB.n0 EVEN_QB.t1 0.228
R1583 EVEN_QB.n0 EVEN_QB.t2 0.228
R1584 EVEN_QB.n3 EVEN_QB.t4 0.20525
R1585 EVEN_QB.n3 EVEN_QB.t6 0.20525
R1586 EVEN_QB.n2 EVEN_QB.n1 0.0952368
R1587 EVEN_Q.n5 EVEN_Q.n2 13.1092
R1588 EVEN_Q EVEN_Q.n5 11.0553
R1589 EVEN_Q.n1 EVEN_Q.t1 5.73764
R1590 EVEN_Q.n2 EVEN_Q.t5 5.6429
R1591 EVEN_Q.n4 EVEN_Q.t2 5.63749
R1592 EVEN_Q.n4 EVEN_Q.n3 5.52748
R1593 EVEN_Q.n1 EVEN_Q.n0 5.32067
R1594 EVEN_Q.n5 EVEN_Q.n4 4.5005
R1595 EVEN_Q.n0 EVEN_Q.t4 0.228
R1596 EVEN_Q.n0 EVEN_Q.t0 0.228
R1597 EVEN_Q.n3 EVEN_Q.t3 0.20525
R1598 EVEN_Q.n3 EVEN_Q.t6 0.20525
R1599 EVEN_Q.n2 EVEN_Q.n1 0.0952368
R1600 O_CAPTURE_CLKB.n17 O_CAPTURE_CLKB.t0 113.632
R1601 O_CAPTURE_CLKB.n5 O_CAPTURE_CLKB.t8 113.632
R1602 O_CAPTURE_CLKB.n26 O_CAPTURE_CLKB.t7 109.174
R1603 O_CAPTURE_CLKB.n25 O_CAPTURE_CLKB.t6 109.174
R1604 O_CAPTURE_CLKB.n24 O_CAPTURE_CLKB.t5 109.174
R1605 O_CAPTURE_CLKB.n15 O_CAPTURE_CLKB.t4 109.174
R1606 O_CAPTURE_CLKB.n20 O_CAPTURE_CLKB.t3 109.174
R1607 O_CAPTURE_CLKB.n19 O_CAPTURE_CLKB.t2 109.174
R1608 O_CAPTURE_CLKB.n18 O_CAPTURE_CLKB.t1 109.174
R1609 O_CAPTURE_CLKB.n6 O_CAPTURE_CLKB.t9 109.174
R1610 O_CAPTURE_CLKB.n7 O_CAPTURE_CLKB.t10 109.174
R1611 O_CAPTURE_CLKB.n8 O_CAPTURE_CLKB.t11 109.174
R1612 O_CAPTURE_CLKB.n9 O_CAPTURE_CLKB.t12 109.174
R1613 O_CAPTURE_CLKB.n10 O_CAPTURE_CLKB.t13 109.174
R1614 O_CAPTURE_CLKB.n11 O_CAPTURE_CLKB.t14 109.174
R1615 O_CAPTURE_CLKB.n12 O_CAPTURE_CLKB.t15 109.174
R1616 O_CAPTURE_CLKB O_CAPTURE_CLKB.n28 47.0442
R1617 O_CAPTURE_CLKB.n27 O_CAPTURE_CLKB.n26 18.4942
R1618 O_CAPTURE_CLKB.n25 O_CAPTURE_CLKB.n14 18.4942
R1619 O_CAPTURE_CLKB.n24 O_CAPTURE_CLKB.n23 18.4942
R1620 O_CAPTURE_CLKB.n22 O_CAPTURE_CLKB.n15 18.4942
R1621 O_CAPTURE_CLKB.n21 O_CAPTURE_CLKB.n20 18.4942
R1622 O_CAPTURE_CLKB.n19 O_CAPTURE_CLKB.n16 18.4942
R1623 O_CAPTURE_CLKB.n7 O_CAPTURE_CLKB.n4 18.4942
R1624 O_CAPTURE_CLKB.n8 O_CAPTURE_CLKB.n3 18.4942
R1625 O_CAPTURE_CLKB.n9 O_CAPTURE_CLKB.n2 18.4942
R1626 O_CAPTURE_CLKB.n10 O_CAPTURE_CLKB.n1 18.4942
R1627 O_CAPTURE_CLKB.n11 O_CAPTURE_CLKB.n0 18.4942
R1628 O_CAPTURE_CLKB.n13 O_CAPTURE_CLKB.n12 18.4942
R1629 O_CAPTURE_CLKB.n28 O_CAPTURE_CLKB.n13 14.2555
R1630 O_CAPTURE_CLKB.n26 O_CAPTURE_CLKB.n25 11.6805
R1631 O_CAPTURE_CLKB.n25 O_CAPTURE_CLKB.n24 11.6805
R1632 O_CAPTURE_CLKB.n24 O_CAPTURE_CLKB.n15 11.6805
R1633 O_CAPTURE_CLKB.n20 O_CAPTURE_CLKB.n15 11.6805
R1634 O_CAPTURE_CLKB.n20 O_CAPTURE_CLKB.n19 11.6805
R1635 O_CAPTURE_CLKB.n19 O_CAPTURE_CLKB.n18 11.6805
R1636 O_CAPTURE_CLKB.n7 O_CAPTURE_CLKB.n6 11.6805
R1637 O_CAPTURE_CLKB.n8 O_CAPTURE_CLKB.n7 11.6805
R1638 O_CAPTURE_CLKB.n9 O_CAPTURE_CLKB.n8 11.6805
R1639 O_CAPTURE_CLKB.n10 O_CAPTURE_CLKB.n9 11.6805
R1640 O_CAPTURE_CLKB.n11 O_CAPTURE_CLKB.n10 11.6805
R1641 O_CAPTURE_CLKB.n12 O_CAPTURE_CLKB.n11 11.6805
R1642 O_CAPTURE_CLKB.n28 O_CAPTURE_CLKB.n27 9.1685
R1643 O_CAPTURE_CLKB.n17 O_CAPTURE_CLKB.n16 7.17687
R1644 O_CAPTURE_CLKB.n5 O_CAPTURE_CLKB.n4 7.17687
R1645 O_CAPTURE_CLKB.n18 O_CAPTURE_CLKB.n17 4.42851
R1646 O_CAPTURE_CLKB.n6 O_CAPTURE_CLKB.n5 4.42851
R1647 O_CAPTURE_CLKB.n27 O_CAPTURE_CLKB.n14 0.1205
R1648 O_CAPTURE_CLKB.n23 O_CAPTURE_CLKB.n14 0.1205
R1649 O_CAPTURE_CLKB.n23 O_CAPTURE_CLKB.n22 0.1205
R1650 O_CAPTURE_CLKB.n22 O_CAPTURE_CLKB.n21 0.1205
R1651 O_CAPTURE_CLKB.n21 O_CAPTURE_CLKB.n16 0.1205
R1652 O_CAPTURE_CLKB.n13 O_CAPTURE_CLKB.n0 0.1205
R1653 O_CAPTURE_CLKB.n1 O_CAPTURE_CLKB.n0 0.1205
R1654 O_CAPTURE_CLKB.n2 O_CAPTURE_CLKB.n1 0.1205
R1655 O_CAPTURE_CLKB.n3 O_CAPTURE_CLKB.n2 0.1205
R1656 O_CAPTURE_CLKB.n4 O_CAPTURE_CLKB.n3 0.1205
R1657 E_CAPTURE_CLKB.n17 E_CAPTURE_CLKB.t0 113.632
R1658 E_CAPTURE_CLKB.n5 E_CAPTURE_CLKB.t8 113.632
R1659 E_CAPTURE_CLKB.n26 E_CAPTURE_CLKB.t7 109.174
R1660 E_CAPTURE_CLKB.n25 E_CAPTURE_CLKB.t6 109.174
R1661 E_CAPTURE_CLKB.n24 E_CAPTURE_CLKB.t5 109.174
R1662 E_CAPTURE_CLKB.n15 E_CAPTURE_CLKB.t4 109.174
R1663 E_CAPTURE_CLKB.n20 E_CAPTURE_CLKB.t3 109.174
R1664 E_CAPTURE_CLKB.n19 E_CAPTURE_CLKB.t2 109.174
R1665 E_CAPTURE_CLKB.n18 E_CAPTURE_CLKB.t1 109.174
R1666 E_CAPTURE_CLKB.n6 E_CAPTURE_CLKB.t9 109.174
R1667 E_CAPTURE_CLKB.n7 E_CAPTURE_CLKB.t10 109.174
R1668 E_CAPTURE_CLKB.n8 E_CAPTURE_CLKB.t11 109.174
R1669 E_CAPTURE_CLKB.n9 E_CAPTURE_CLKB.t12 109.174
R1670 E_CAPTURE_CLKB.n10 E_CAPTURE_CLKB.t13 109.174
R1671 E_CAPTURE_CLKB.n11 E_CAPTURE_CLKB.t14 109.174
R1672 E_CAPTURE_CLKB.n12 E_CAPTURE_CLKB.t15 109.174
R1673 E_CAPTURE_CLKB E_CAPTURE_CLKB.n28 29.0413
R1674 E_CAPTURE_CLKB.n27 E_CAPTURE_CLKB.n26 18.4942
R1675 E_CAPTURE_CLKB.n25 E_CAPTURE_CLKB.n14 18.4942
R1676 E_CAPTURE_CLKB.n24 E_CAPTURE_CLKB.n23 18.4942
R1677 E_CAPTURE_CLKB.n22 E_CAPTURE_CLKB.n15 18.4942
R1678 E_CAPTURE_CLKB.n21 E_CAPTURE_CLKB.n20 18.4942
R1679 E_CAPTURE_CLKB.n19 E_CAPTURE_CLKB.n16 18.4942
R1680 E_CAPTURE_CLKB.n7 E_CAPTURE_CLKB.n4 18.4942
R1681 E_CAPTURE_CLKB.n8 E_CAPTURE_CLKB.n3 18.4942
R1682 E_CAPTURE_CLKB.n9 E_CAPTURE_CLKB.n2 18.4942
R1683 E_CAPTURE_CLKB.n10 E_CAPTURE_CLKB.n1 18.4942
R1684 E_CAPTURE_CLKB.n11 E_CAPTURE_CLKB.n0 18.4942
R1685 E_CAPTURE_CLKB.n13 E_CAPTURE_CLKB.n12 18.4942
R1686 E_CAPTURE_CLKB.n28 E_CAPTURE_CLKB.n13 14.2555
R1687 E_CAPTURE_CLKB.n26 E_CAPTURE_CLKB.n25 11.6805
R1688 E_CAPTURE_CLKB.n25 E_CAPTURE_CLKB.n24 11.6805
R1689 E_CAPTURE_CLKB.n24 E_CAPTURE_CLKB.n15 11.6805
R1690 E_CAPTURE_CLKB.n20 E_CAPTURE_CLKB.n15 11.6805
R1691 E_CAPTURE_CLKB.n20 E_CAPTURE_CLKB.n19 11.6805
R1692 E_CAPTURE_CLKB.n19 E_CAPTURE_CLKB.n18 11.6805
R1693 E_CAPTURE_CLKB.n7 E_CAPTURE_CLKB.n6 11.6805
R1694 E_CAPTURE_CLKB.n8 E_CAPTURE_CLKB.n7 11.6805
R1695 E_CAPTURE_CLKB.n9 E_CAPTURE_CLKB.n8 11.6805
R1696 E_CAPTURE_CLKB.n10 E_CAPTURE_CLKB.n9 11.6805
R1697 E_CAPTURE_CLKB.n11 E_CAPTURE_CLKB.n10 11.6805
R1698 E_CAPTURE_CLKB.n12 E_CAPTURE_CLKB.n11 11.6805
R1699 E_CAPTURE_CLKB.n28 E_CAPTURE_CLKB.n27 9.1685
R1700 E_CAPTURE_CLKB.n17 E_CAPTURE_CLKB.n16 7.17687
R1701 E_CAPTURE_CLKB.n5 E_CAPTURE_CLKB.n4 7.17687
R1702 E_CAPTURE_CLKB.n18 E_CAPTURE_CLKB.n17 4.42851
R1703 E_CAPTURE_CLKB.n6 E_CAPTURE_CLKB.n5 4.42851
R1704 E_CAPTURE_CLKB.n27 E_CAPTURE_CLKB.n14 0.1205
R1705 E_CAPTURE_CLKB.n23 E_CAPTURE_CLKB.n14 0.1205
R1706 E_CAPTURE_CLKB.n23 E_CAPTURE_CLKB.n22 0.1205
R1707 E_CAPTURE_CLKB.n22 E_CAPTURE_CLKB.n21 0.1205
R1708 E_CAPTURE_CLKB.n21 E_CAPTURE_CLKB.n16 0.1205
R1709 E_CAPTURE_CLKB.n13 E_CAPTURE_CLKB.n0 0.1205
R1710 E_CAPTURE_CLKB.n1 E_CAPTURE_CLKB.n0 0.1205
R1711 E_CAPTURE_CLKB.n2 E_CAPTURE_CLKB.n1 0.1205
R1712 E_CAPTURE_CLKB.n3 E_CAPTURE_CLKB.n2 0.1205
R1713 E_CAPTURE_CLKB.n4 E_CAPTURE_CLKB.n3 0.1205
R1714 VDD.t6 VDD.t5 2823.53
R1715 VDD.t8 VDD.t7 2823.53
R1716 VDD.t7 VDD.t6 1411.76
R1717 VDD.n5 VDD.t246 923.077
R1718 VDD.n6 VDD.t9 923.077
R1719 VDD.n10 VDD.t334 923.077
R1720 VDD.n11 VDD.t432 923.077
R1721 VDD.n15 VDD.t17 923.077
R1722 VDD.n16 VDD.t13 923.077
R1723 VDD.t12 VDD.t248 640.625
R1724 VDD.t337 VDD.t11 640.625
R1725 VDD.t435 VDD.t336 640.625
R1726 VDD.t20 VDD.t434 640.625
R1727 VDD.t16 VDD.t19 640.625
R1728 VDD.t30 VDD.t15 640.625
R1729 VDD.n3 VDD.t246 483.238
R1730 VDD.t9 VDD.n5 461.538
R1731 VDD.n6 VDD.t334 461.538
R1732 VDD.t432 VDD.n10 461.538
R1733 VDD.n11 VDD.t17 461.538
R1734 VDD.t13 VDD.n15 461.538
R1735 VDD.n16 VDD.t27 461.538
R1736 VDD.n38 VDD.t8 407.682
R1737 VDD.n19 VDD.t29 313.457
R1738 VDD.n370 VDD.n360 166.667
R1739 VDD.n372 VDD.n371 166.667
R1740 VDD.n398 VDD.n328 166.667
R1741 VDD.n400 VDD.n399 166.667
R1742 VDD.n164 VDD.n163 166.667
R1743 VDD.n155 VDD.n154 166.667
R1744 VDD.n122 VDD.n105 166.667
R1745 VDD.n114 VDD.n113 166.667
R1746 VDD.n275 VDD.n272 166.667
R1747 VDD.n272 VDD.n271 166.667
R1748 VDD.t460 VDD.n273 126.668
R1749 VDD.n262 VDD.t164 126.668
R1750 VDD.n371 VDD.t395 120.001
R1751 VDD.t436 VDD.n398 120.001
R1752 VDD.n154 VDD.t470 120.001
R1753 VDD.t391 VDD.n105 120.001
R1754 VDD.n379 VDD.t427 113.334
R1755 VDD.t1 VDD.t202 113.334
R1756 VDD.t209 VDD.t51 113.334
R1757 VDD.n337 VDD.t135 113.334
R1758 VDD.n139 VDD.t387 113.334
R1759 VDD.t383 VDD.t297 113.334
R1760 VDD.t304 VDD.t243 113.334
R1761 VDD.t239 VDD.n128 113.334
R1762 VDD.t156 VDD.n297 113.334
R1763 VDD.n289 VDD.t100 113.334
R1764 VDD.t0 VDD.n256 113.334
R1765 VDD.n248 VDD.t347 113.334
R1766 VDD.n365 VDD.n364 106.3
R1767 VDD.n326 VDD.n324 106.3
R1768 VDD.n166 VDD.n165 106.3
R1769 VDD.n112 VDD.n111 106.3
R1770 VDD.n300 VDD.n299 106.3
R1771 VDD.n245 VDD.n244 106.3
R1772 VDD.n372 VDD.t381 80.0005
R1773 VDD.n380 VDD.t200 80.0005
R1774 VDD.n388 VDD.t212 80.0005
R1775 VDD.t257 VDD.n328 80.0005
R1776 VDD.n155 VDD.t345 80.0005
R1777 VDD.n140 VDD.t273 80.0005
R1778 VDD.t307 VDD.n127 80.0005
R1779 VDD.t168 VDD.n122 80.0005
R1780 VDD.n365 VDD.n361 70.0005
R1781 VDD.n369 VDD.n361 70.0005
R1782 VDD.n369 VDD.n355 70.0005
R1783 VDD.n373 VDD.n355 70.0005
R1784 VDD.n373 VDD.n349 70.0005
R1785 VDD.n377 VDD.n349 70.0005
R1786 VDD.n377 VDD.n347 70.0005
R1787 VDD.n382 VDD.n347 70.0005
R1788 VDD.n382 VDD.n339 70.0005
R1789 VDD.n386 VDD.n339 70.0005
R1790 VDD.n386 VDD.n338 70.0005
R1791 VDD.n338 VDD.n334 70.0005
R1792 VDD.n393 VDD.n334 70.0005
R1793 VDD.n393 VDD.n329 70.0005
R1794 VDD.n397 VDD.n329 70.0005
R1795 VDD.n397 VDD.n325 70.0005
R1796 VDD.n401 VDD.n325 70.0005
R1797 VDD.n401 VDD.n324 70.0005
R1798 VDD.n166 VDD.n87 70.0005
R1799 VDD.n162 VDD.n87 70.0005
R1800 VDD.n162 VDD.n88 70.0005
R1801 VDD.n156 VDD.n88 70.0005
R1802 VDD.n156 VDD.n92 70.0005
R1803 VDD.n148 VDD.n92 70.0005
R1804 VDD.n148 VDD.n94 70.0005
R1805 VDD.n142 VDD.n94 70.0005
R1806 VDD.n142 VDD.n98 70.0005
R1807 VDD.n136 VDD.n98 70.0005
R1808 VDD.n136 VDD.n99 70.0005
R1809 VDD.n130 VDD.n99 70.0005
R1810 VDD.n130 VDD.n103 70.0005
R1811 VDD.n121 VDD.n103 70.0005
R1812 VDD.n121 VDD.n106 70.0005
R1813 VDD.n115 VDD.n106 70.0005
R1814 VDD.n115 VDD.n110 70.0005
R1815 VDD.n111 VDD.n110 70.0005
R1816 VDD.n300 VDD.n221 70.0005
R1817 VDD.n296 VDD.n221 70.0005
R1818 VDD.n296 VDD.n222 70.0005
R1819 VDD.n290 VDD.n222 70.0005
R1820 VDD.n290 VDD.n226 70.0005
R1821 VDD.n282 VDD.n226 70.0005
R1822 VDD.n282 VDD.n228 70.0005
R1823 VDD.n276 VDD.n228 70.0005
R1824 VDD.n276 VDD.n232 70.0005
R1825 VDD.n270 VDD.n232 70.0005
R1826 VDD.n270 VDD.n233 70.0005
R1827 VDD.n264 VDD.n233 70.0005
R1828 VDD.n264 VDD.n237 70.0005
R1829 VDD.n255 VDD.n237 70.0005
R1830 VDD.n255 VDD.n239 70.0005
R1831 VDD.n249 VDD.n239 70.0005
R1832 VDD.n249 VDD.n243 70.0005
R1833 VDD.n244 VDD.n243 70.0005
R1834 VDD.n364 VDD.n360 66.6672
R1835 VDD.n400 VDD.n326 66.6672
R1836 VDD.n165 VDD.n164 66.6672
R1837 VDD.n113 VDD.n112 66.6672
R1838 VDD.n299 VDD.n298 66.6672
R1839 VDD.n285 VDD.n284 66.6672
R1840 VDD.n258 VDD.n257 66.6672
R1841 VDD.n246 VDD.n245 66.6672
R1842 VDD.t248 VDD.t249 62.5005
R1843 VDD.t11 VDD.t12 62.5005
R1844 VDD.t336 VDD.t337 62.5005
R1845 VDD.t434 VDD.t435 62.5005
R1846 VDD.t19 VDD.t20 62.5005
R1847 VDD.t15 VDD.t16 62.5005
R1848 VDD.t29 VDD.t30 62.5005
R1849 VDD.n288 VDD.t369 53.3338
R1850 VDD.t86 VDD.n288 53.3338
R1851 VDD.n285 VDD.t416 53.3338
R1852 VDD.n258 VDD.t121 53.3338
R1853 VDD.n247 VDD.t77 53.3338
R1854 VDD.t31 VDD.n247 53.3338
R1855 VDD.n356 VDD.t438 46.6672
R1856 VDD.n392 VDD.t254 46.6672
R1857 VDD.n150 VDD.t393 46.6672
R1858 VDD.n123 VDD.t468 46.6672
R1859 VDD.n273 VDD.t61 46.6672
R1860 VDD.t353 VDD.n262 46.6672
R1861 VDD.n378 VDD.t192 40.0005
R1862 VDD.n336 VDD.t218 40.0005
R1863 VDD.t281 VDD.n149 40.0005
R1864 VDD.n129 VDD.t313 40.0005
R1865 VDD.t450 VDD.t405 33.3338
R1866 VDD.t111 VDD.t456 33.3338
R1867 VDD.t3 VDD.n380 26.6672
R1868 VDD.n388 VDD.t49 26.6672
R1869 VDD.t385 VDD.n140 26.6672
R1870 VDD.n127 VDD.t241 26.6672
R1871 VDD.n275 VDD.t458 26.6672
R1872 VDD.n271 VDD.t166 26.6672
R1873 VDD.n525 VDD.n524 25.203
R1874 VDD.n561 VDD.n560 25.203
R1875 VDD.n31 VDD.t56 25.1121
R1876 VDD.n33 VDD.t238 24.7565
R1877 VDD.n37 VDD.t131 24.7565
R1878 VDD.n34 VDD.t48 24.7565
R1879 VDD.n21 VDD.t431 22.412
R1880 VDD.n548 VDD.n547 22.1735
R1881 VDD.n28 VDD.t53 22.1461
R1882 VDD.n22 VDD.t147 21.9835
R1883 VDD.n39 VDD.t333 21.9006
R1884 VDD.n40 VDD.t170 21.9006
R1885 VDD.n25 VDD.t54 21.7356
R1886 VDD.n24 VDD.t479 21.7356
R1887 VDD.n21 VDD.t55 21.612
R1888 VDD.n17 VDD.n16 21.6005
R1889 VDD.n15 VDD.n14 21.6005
R1890 VDD.n12 VDD.n11 21.6005
R1891 VDD.n10 VDD.n9 21.6005
R1892 VDD.n7 VDD.n6 21.6005
R1893 VDD.n5 VDD.n4 21.6005
R1894 VDD.n22 VDD.t148 21.5835
R1895 VDD.n39 VDD.t60 21.545
R1896 VDD.n40 VDD.t146 21.545
R1897 VDD.n36 VDD.t47 21.4505
R1898 VDD.n35 VDD.t79 21.4505
R1899 VDD.n28 VDD.t478 21.435
R1900 VDD.n30 VDD.t173 21.435
R1901 VDD.n29 VDD.t245 21.435
R1902 VDD.n32 VDD.t132 21.3935
R1903 VDD.n31 VDD.t338 21.3935
R1904 VDD.n25 VDD.t256 21.38
R1905 VDD.n24 VDD.t96 21.38
R1906 VDD.t259 VDD.n370 20.0005
R1907 VDD.n399 VDD.t138 20.0005
R1908 VDD.n163 VDD.t151 20.0005
R1909 VDD.n114 VDD.t371 20.0005
R1910 VDD.n297 VDD.t359 20.0005
R1911 VDD.n289 VDD.t94 20.0005
R1912 VDD.n256 VDD.t63 20.0005
R1913 VDD.n248 VDD.t45 20.0005
R1914 VDD.n444 VDD.n443 19.9029
R1915 VDD.n64 VDD.n63 19.9029
R1916 VDD.n441 VDD.n440 19.8556
R1917 VDD.n192 VDD.n191 19.8556
R1918 VDD.n510 VDD.n503 19.5039
R1919 VDD.n579 VDD.n572 19.5039
R1920 VDD.n516 VDD.n514 19.4092
R1921 VDD.n523 VDD.n522 19.4092
R1922 VDD.n564 VDD.n562 19.4092
R1923 VDD.n571 VDD.n570 19.4092
R1924 VDD.n408 VDD.n407 19.0889
R1925 VDD.n475 VDD.n474 19.0889
R1926 VDD.n46 VDD.n45 19.0889
R1927 VDD.n83 VDD.n82 19.0889
R1928 VDD.n416 VDD.n415 19.0179
R1929 VDD.n421 VDD.n420 19.0179
R1930 VDD.n457 VDD.n456 19.0179
R1931 VDD.n307 VDD.n306 19.0179
R1932 VDD.n213 VDD.n212 19.0179
R1933 VDD.n62 VDD.n61 19.0179
R1934 VDD.n80 VDD.n79 19.0179
R1935 VDD.n177 VDD.n176 19.0179
R1936 VDD.n302 VDD.n301 18.3116
R1937 VDD.n404 VDD.n321 18.1338
R1938 VDD.n168 VDD.n167 18.1338
R1939 VDD.n368 VDD.n363 18.0005
R1940 VDD.n362 VDD.n354 18.0005
R1941 VDD.n374 VDD.n353 18.0005
R1942 VDD.n375 VDD.n352 18.0005
R1943 VDD.n376 VDD.n351 18.0005
R1944 VDD.n350 VDD.n346 18.0005
R1945 VDD.n383 VDD.n345 18.0005
R1946 VDD.n384 VDD.n344 18.0005
R1947 VDD.n385 VDD.n343 18.0005
R1948 VDD.n342 VDD.n340 18.0005
R1949 VDD.n341 VDD.n333 18.0005
R1950 VDD.n394 VDD.n332 18.0005
R1951 VDD.n395 VDD.n331 18.0005
R1952 VDD.n396 VDD.n330 18.0005
R1953 VDD.n323 VDD.n322 18.0005
R1954 VDD.n403 VDD.n402 18.0005
R1955 VDD.n86 VDD.n85 18.0005
R1956 VDD.n161 VDD.n160 18.0005
R1957 VDD.n159 VDD.n89 18.0005
R1958 VDD.n158 VDD.n157 18.0005
R1959 VDD.n91 VDD.n90 18.0005
R1960 VDD.n147 VDD.n146 18.0005
R1961 VDD.n145 VDD.n95 18.0005
R1962 VDD.n144 VDD.n143 18.0005
R1963 VDD.n97 VDD.n96 18.0005
R1964 VDD.n135 VDD.n134 18.0005
R1965 VDD.n133 VDD.n100 18.0005
R1966 VDD.n132 VDD.n131 18.0005
R1967 VDD.n102 VDD.n101 18.0005
R1968 VDD.n120 VDD.n119 18.0005
R1969 VDD.n118 VDD.n107 18.0005
R1970 VDD.n117 VDD.n116 18.0005
R1971 VDD.n220 VDD.n219 18.0005
R1972 VDD.n295 VDD.n294 18.0005
R1973 VDD.n293 VDD.n223 18.0005
R1974 VDD.n292 VDD.n291 18.0005
R1975 VDD.n225 VDD.n224 18.0005
R1976 VDD.n281 VDD.n280 18.0005
R1977 VDD.n279 VDD.n229 18.0005
R1978 VDD.n278 VDD.n277 18.0005
R1979 VDD.n231 VDD.n230 18.0005
R1980 VDD.n269 VDD.n268 18.0005
R1981 VDD.n267 VDD.n234 18.0005
R1982 VDD.n266 VDD.n265 18.0005
R1983 VDD.n236 VDD.n235 18.0005
R1984 VDD.n254 VDD.n253 18.0005
R1985 VDD.n252 VDD.n240 18.0005
R1986 VDD.n251 VDD.n250 18.0005
R1987 VDD.n245 VDD.n238 17.6847
R1988 VDD.n364 VDD.n359 17.639
R1989 VDD.n112 VDD.n104 17.6387
R1990 VDD.n534 VDD.n526 16.9481
R1991 VDD.n317 VDD.n316 16.6701
R1992 VDD.n312 VDD.n311 16.6701
R1993 VDD.n200 VDD.n199 16.6701
R1994 VDD.n189 VDD.n188 16.6701
R1995 VDD.n299 VDD.n218 16.4744
R1996 VDD.n288 VDD.n287 16.4218
R1997 VDD.n286 VDD.n285 16.4218
R1998 VDD.n274 VDD.n227 16.4218
R1999 VDD.n261 VDD.n260 16.4218
R2000 VDD.n259 VDD.n258 16.4218
R2001 VDD.n247 VDD.n238 16.4218
R2002 VDD.n371 VDD.n359 16.3758
R2003 VDD.n358 VDD.n357 16.3758
R2004 VDD.n380 VDD.n335 16.3758
R2005 VDD.n389 VDD.n388 16.3758
R2006 VDD.n391 VDD.n390 16.3758
R2007 VDD.n398 VDD.n327 16.3758
R2008 VDD.n165 VDD.n84 16.3758
R2009 VDD.n154 VDD.n153 16.3758
R2010 VDD.n152 VDD.n151 16.3758
R2011 VDD.n140 VDD.n93 16.3758
R2012 VDD.n127 VDD.n126 16.3758
R2013 VDD.n125 VDD.n124 16.3758
R2014 VDD.n105 VDD.n104 16.3758
R2015 VDD.n326 VDD.n320 16.3756
R2016 VDD.n503 VDD.n502 14.6703
R2017 VDD.n452 VDD.n451 14.4407
R2018 VDD.n205 VDD.n204 14.4407
R2019 VDD.n435 VDD.n434 14.3222
R2020 VDD.n185 VDD.n184 14.3222
R2021 VDD.n498 VDD.n494 13.7564
R2022 VDD.n586 VDD.n585 13.4387
R2023 VDD.t397 VDD.t259 13.3338
R2024 VDD.t395 VDD.t397 13.3338
R2025 VDD.t379 VDD.t381 13.3338
R2026 VDD.t440 VDD.t379 13.3338
R2027 VDD.t438 VDD.t440 13.3338
R2028 VDD.t178 VDD.t176 13.3338
R2029 VDD.t180 VDD.t178 13.3338
R2030 VDD.t182 VDD.t180 13.3338
R2031 VDD.t174 VDD.t182 13.3338
R2032 VDD.t162 VDD.n378 13.3338
R2033 VDD.t160 VDD.t162 13.3338
R2034 VDD.t429 VDD.t160 13.3338
R2035 VDD.t427 VDD.t429 13.3338
R2036 VDD.t196 VDD.n379 13.3338
R2037 VDD.t198 VDD.t196 13.3338
R2038 VDD.t194 VDD.t198 13.3338
R2039 VDD.t200 VDD.t194 13.3338
R2040 VDD.t202 VDD.t203 13.3338
R2041 VDD.t203 VDD.t204 13.3338
R2042 VDD.t204 VDD.t205 13.3338
R2043 VDD.t206 VDD.t207 13.3338
R2044 VDD.t207 VDD.t208 13.3338
R2045 VDD.t208 VDD.t209 13.3338
R2046 VDD.t210 VDD.t212 13.3338
R2047 VDD.t214 VDD.t210 13.3338
R2048 VDD.t216 VDD.t214 13.3338
R2049 VDD.n337 VDD.t216 13.3338
R2050 VDD.t135 VDD.t133 13.3338
R2051 VDD.t133 VDD.t351 13.3338
R2052 VDD.t351 VDD.t349 13.3338
R2053 VDD.t349 VDD.n336 13.3338
R2054 VDD.t230 VDD.t228 13.3338
R2055 VDD.t232 VDD.t230 13.3338
R2056 VDD.t234 VDD.t232 13.3338
R2057 VDD.t236 VDD.t234 13.3338
R2058 VDD.t254 VDD.t252 13.3338
R2059 VDD.t252 VDD.t250 13.3338
R2060 VDD.t250 VDD.t257 13.3338
R2061 VDD.t140 VDD.t436 13.3338
R2062 VDD.t138 VDD.t140 13.3338
R2063 VDD.t149 VDD.t151 13.3338
R2064 VDD.t470 VDD.t149 13.3338
R2065 VDD.t343 VDD.t345 13.3338
R2066 VDD.t341 VDD.t343 13.3338
R2067 VDD.t393 VDD.t341 13.3338
R2068 VDD.t279 VDD.t277 13.3338
R2069 VDD.t285 VDD.t279 13.3338
R2070 VDD.t287 VDD.t285 13.3338
R2071 VDD.t289 VDD.t287 13.3338
R2072 VDD.n149 VDD.t377 13.3338
R2073 VDD.t375 VDD.t377 13.3338
R2074 VDD.t373 VDD.t375 13.3338
R2075 VDD.t387 VDD.t373 13.3338
R2076 VDD.t269 VDD.n139 13.3338
R2077 VDD.t271 VDD.t269 13.3338
R2078 VDD.t295 VDD.t271 13.3338
R2079 VDD.t273 VDD.t295 13.3338
R2080 VDD.t297 VDD.t298 13.3338
R2081 VDD.t298 VDD.t299 13.3338
R2082 VDD.t299 VDD.t300 13.3338
R2083 VDD.t301 VDD.t302 13.3338
R2084 VDD.t302 VDD.t303 13.3338
R2085 VDD.t303 VDD.t304 13.3338
R2086 VDD.t309 VDD.t307 13.3338
R2087 VDD.t305 VDD.t309 13.3338
R2088 VDD.t311 VDD.t305 13.3338
R2089 VDD.n128 VDD.t311 13.3338
R2090 VDD.t484 VDD.t239 13.3338
R2091 VDD.t482 VDD.t484 13.3338
R2092 VDD.t480 VDD.t482 13.3338
R2093 VDD.n129 VDD.t480 13.3338
R2094 VDD.t323 VDD.t325 13.3338
R2095 VDD.t325 VDD.t327 13.3338
R2096 VDD.t327 VDD.t329 13.3338
R2097 VDD.t329 VDD.t331 13.3338
R2098 VDD.t468 VDD.t466 13.3338
R2099 VDD.t466 VDD.t464 13.3338
R2100 VDD.t464 VDD.t168 13.3338
R2101 VDD.t389 VDD.t391 13.3338
R2102 VDD.t371 VDD.t389 13.3338
R2103 VDD.n298 VDD.t462 13.3338
R2104 VDD.t462 VDD.t442 13.3338
R2105 VDD.t442 VDD.t25 13.3338
R2106 VDD.t25 VDD.t156 13.3338
R2107 VDD.t365 VDD.t359 13.3338
R2108 VDD.t363 VDD.t365 13.3338
R2109 VDD.t355 VDD.t363 13.3338
R2110 VDD.t357 VDD.t355 13.3338
R2111 VDD.t367 VDD.t357 13.3338
R2112 VDD.t361 VDD.t367 13.3338
R2113 VDD.t369 VDD.t361 13.3338
R2114 VDD.t82 VDD.t86 13.3338
R2115 VDD.t84 VDD.t82 13.3338
R2116 VDD.t88 VDD.t84 13.3338
R2117 VDD.t90 VDD.t88 13.3338
R2118 VDD.t92 VDD.t90 13.3338
R2119 VDD.t80 VDD.t92 13.3338
R2120 VDD.t94 VDD.t80 13.3338
R2121 VDD.t99 VDD.t100 13.3338
R2122 VDD.t59 VDD.t99 13.3338
R2123 VDD.t58 VDD.t59 13.3338
R2124 VDD.n284 VDD.t58 13.3338
R2125 VDD.t416 VDD.t414 13.3338
R2126 VDD.t414 VDD.t407 13.3338
R2127 VDD.t407 VDD.t263 13.3338
R2128 VDD.t411 VDD.t261 13.3338
R2129 VDD.t409 VDD.t411 13.3338
R2130 VDD.t405 VDD.t409 13.3338
R2131 VDD.t142 VDD.t450 13.3338
R2132 VDD.t144 VDD.t142 13.3338
R2133 VDD.t61 VDD.t144 13.3338
R2134 VDD.t403 VDD.t353 13.3338
R2135 VDD.t444 VDD.t403 13.3338
R2136 VDD.t456 VDD.t444 13.3338
R2137 VDD.t115 VDD.t111 13.3338
R2138 VDD.t113 VDD.t115 13.3338
R2139 VDD.t107 VDD.t113 13.3338
R2140 VDD.t117 VDD.t109 13.3338
R2141 VDD.t119 VDD.t117 13.3338
R2142 VDD.t121 VDD.t119 13.3338
R2143 VDD.n257 VDD.t57 13.3338
R2144 VDD.t57 VDD.t98 13.3338
R2145 VDD.t98 VDD.t97 13.3338
R2146 VDD.t97 VDD.t0 13.3338
R2147 VDD.t65 VDD.t63 13.3338
R2148 VDD.t67 VDD.t65 13.3338
R2149 VDD.t69 VDD.t67 13.3338
R2150 VDD.t71 VDD.t69 13.3338
R2151 VDD.t73 VDD.t71 13.3338
R2152 VDD.t75 VDD.t73 13.3338
R2153 VDD.t77 VDD.t75 13.3338
R2154 VDD.t33 VDD.t31 13.3338
R2155 VDD.t35 VDD.t33 13.3338
R2156 VDD.t37 VDD.t35 13.3338
R2157 VDD.t39 VDD.t37 13.3338
R2158 VDD.t41 VDD.t39 13.3338
R2159 VDD.t43 VDD.t41 13.3338
R2160 VDD.t45 VDD.t43 13.3338
R2161 VDD.t347 VDD.t452 13.3338
R2162 VDD.t452 VDD.t454 13.3338
R2163 VDD.t454 VDD.t401 13.3338
R2164 VDD.t401 VDD.n246 13.3338
R2165 VDD.n20 VDD.n19 13.26
R2166 VDD.n535 VDD.n499 13.2291
R2167 VDD.n492 VDD.n479 13.2291
R2168 VDD.n557 VDD.n549 12.3348
R2169 VDD.n513 VDD.n512 11.9744
R2170 VDD.n582 VDD.n581 11.9744
R2171 VDD.n3 VDD.t247 11.724
R2172 VDD.n2 VDD.t10 11.724
R2173 VDD.n8 VDD.t335 11.724
R2174 VDD.n1 VDD.t433 11.724
R2175 VDD.n13 VDD.t18 11.724
R2176 VDD.n0 VDD.t14 11.724
R2177 VDD.n18 VDD.t28 11.724
R2178 VDD.n19 VDD.n18 11.1202
R2179 VDD.n512 VDD.n511 10.1049
R2180 VDD.n581 VDD.n580 10.1049
R2181 VDD.n366 VDD.n363 9.31191
R2182 VDD.n117 VDD.n108 9.31191
R2183 VDD.n251 VDD.n241 9.31191
R2184 VDD.n483 VDD.n478 8.84398
R2185 VDD.n591 VDD.n590 8.5845
R2186 VDD.n467 VDD.n466 8.55306
R2187 VDD.n57 VDD.n56 8.55306
R2188 VDD.n431 VDD.n430 8.42404
R2189 VDD.n75 VDD.n74 8.42404
R2190 VDD.n491 VDD.n483 8.00988
R2191 VDD.n512 VDD.n510 7.43528
R2192 VDD.n581 VDD.n579 7.43528
R2193 VDD.n536 VDD.n493 6.88746
R2194 VDD.n546 VDD.n545 6.88746
R2195 VDD.n559 VDD.n558 6.88746
R2196 VDD.n366 VDD.n365 6.79358
R2197 VDD.n111 VDD.n108 6.79358
R2198 VDD.n244 VDD.n241 6.79358
R2199 VDD.t176 VDD.n356 6.66717
R2200 VDD.n357 VDD.t174 6.66717
R2201 VDD.n357 VDD.t186 6.66717
R2202 VDD.t186 VDD.t267 6.66717
R2203 VDD.t267 VDD.t188 6.66717
R2204 VDD.t188 VDD.t265 6.66717
R2205 VDD.t265 VDD.t190 6.66717
R2206 VDD.t190 VDD.t448 6.66717
R2207 VDD.t448 VDD.t184 6.66717
R2208 VDD.t184 VDD.t446 6.66717
R2209 VDD.t446 VDD.t192 6.66717
R2210 VDD.n381 VDD.t3 6.66717
R2211 VDD.n381 VDD.t1 6.66717
R2212 VDD.t205 VDD.n348 6.66717
R2213 VDD.n348 VDD.t206 6.66717
R2214 VDD.n387 VDD.t51 6.66717
R2215 VDD.t49 VDD.n387 6.66717
R2216 VDD.t218 VDD.t23 6.66717
R2217 VDD.t23 VDD.t220 6.66717
R2218 VDD.t220 VDD.t21 6.66717
R2219 VDD.t21 VDD.t222 6.66717
R2220 VDD.t222 VDD.t474 6.66717
R2221 VDD.t474 VDD.t224 6.66717
R2222 VDD.t224 VDD.t472 6.66717
R2223 VDD.t472 VDD.t226 6.66717
R2224 VDD.n391 VDD.t226 6.66717
R2225 VDD.t228 VDD.n391 6.66717
R2226 VDD.n392 VDD.t236 6.66717
R2227 VDD.t277 VDD.n150 6.66717
R2228 VDD.n151 VDD.t289 6.66717
R2229 VDD.n151 VDD.t283 6.66717
R2230 VDD.t283 VDD.t490 6.66717
R2231 VDD.t490 VDD.t291 6.66717
R2232 VDD.t291 VDD.t488 6.66717
R2233 VDD.t488 VDD.t275 6.66717
R2234 VDD.t275 VDD.t486 6.66717
R2235 VDD.t486 VDD.t293 6.66717
R2236 VDD.t293 VDD.t171 6.66717
R2237 VDD.t171 VDD.t281 6.66717
R2238 VDD.n141 VDD.t385 6.66717
R2239 VDD.n141 VDD.t383 6.66717
R2240 VDD.t300 VDD.n138 6.66717
R2241 VDD.n138 VDD.t301 6.66717
R2242 VDD.t243 VDD.n137 6.66717
R2243 VDD.n137 VDD.t241 6.66717
R2244 VDD.t105 VDD.t313 6.66717
R2245 VDD.t315 VDD.t105 6.66717
R2246 VDD.t103 VDD.t315 6.66717
R2247 VDD.t317 VDD.t103 6.66717
R2248 VDD.t101 VDD.t317 6.66717
R2249 VDD.t319 VDD.t101 6.66717
R2250 VDD.t399 VDD.t319 6.66717
R2251 VDD.t321 VDD.t399 6.66717
R2252 VDD.n124 VDD.t321 6.66717
R2253 VDD.n124 VDD.t323 6.66717
R2254 VDD.t331 VDD.n123 6.66717
R2255 VDD.t263 VDD.n283 6.66717
R2256 VDD.n283 VDD.t261 6.66717
R2257 VDD.n274 VDD.t460 6.66717
R2258 VDD.t458 VDD.n274 6.66717
R2259 VDD.n261 VDD.t166 6.66717
R2260 VDD.t164 VDD.n261 6.66717
R2261 VDD.n263 VDD.t107 6.66717
R2262 VDD.n263 VDD.t109 6.66717
R2263 VDD.n324 VDD.n321 6.3005
R2264 VDD.n401 VDD.n400 6.3005
R2265 VDD.n402 VDD.n401 6.3005
R2266 VDD.n399 VDD.n325 6.3005
R2267 VDD.n325 VDD.n323 6.3005
R2268 VDD.n398 VDD.n397 6.3005
R2269 VDD.n397 VDD.n396 6.3005
R2270 VDD.n329 VDD.n328 6.3005
R2271 VDD.n395 VDD.n329 6.3005
R2272 VDD.n393 VDD.n392 6.3005
R2273 VDD.n394 VDD.n393 6.3005
R2274 VDD.n336 VDD.n334 6.3005
R2275 VDD.n334 VDD.n333 6.3005
R2276 VDD.n338 VDD.n337 6.3005
R2277 VDD.n340 VDD.n338 6.3005
R2278 VDD.n387 VDD.n386 6.3005
R2279 VDD.n386 VDD.n385 6.3005
R2280 VDD.n348 VDD.n339 6.3005
R2281 VDD.n384 VDD.n339 6.3005
R2282 VDD.n382 VDD.n381 6.3005
R2283 VDD.n383 VDD.n382 6.3005
R2284 VDD.n379 VDD.n347 6.3005
R2285 VDD.n347 VDD.n346 6.3005
R2286 VDD.n378 VDD.n377 6.3005
R2287 VDD.n377 VDD.n376 6.3005
R2288 VDD.n356 VDD.n349 6.3005
R2289 VDD.n375 VDD.n349 6.3005
R2290 VDD.n373 VDD.n372 6.3005
R2291 VDD.n374 VDD.n373 6.3005
R2292 VDD.n371 VDD.n355 6.3005
R2293 VDD.n355 VDD.n354 6.3005
R2294 VDD.n370 VDD.n369 6.3005
R2295 VDD.n369 VDD.n368 6.3005
R2296 VDD.n361 VDD.n360 6.3005
R2297 VDD.n367 VDD.n361 6.3005
R2298 VDD.n113 VDD.n110 6.3005
R2299 VDD.n110 VDD.n109 6.3005
R2300 VDD.n115 VDD.n114 6.3005
R2301 VDD.n116 VDD.n115 6.3005
R2302 VDD.n106 VDD.n105 6.3005
R2303 VDD.n107 VDD.n106 6.3005
R2304 VDD.n122 VDD.n121 6.3005
R2305 VDD.n121 VDD.n120 6.3005
R2306 VDD.n123 VDD.n103 6.3005
R2307 VDD.n103 VDD.n102 6.3005
R2308 VDD.n130 VDD.n129 6.3005
R2309 VDD.n131 VDD.n130 6.3005
R2310 VDD.n128 VDD.n99 6.3005
R2311 VDD.n100 VDD.n99 6.3005
R2312 VDD.n137 VDD.n136 6.3005
R2313 VDD.n136 VDD.n135 6.3005
R2314 VDD.n138 VDD.n98 6.3005
R2315 VDD.n98 VDD.n97 6.3005
R2316 VDD.n142 VDD.n141 6.3005
R2317 VDD.n143 VDD.n142 6.3005
R2318 VDD.n139 VDD.n94 6.3005
R2319 VDD.n95 VDD.n94 6.3005
R2320 VDD.n149 VDD.n148 6.3005
R2321 VDD.n148 VDD.n147 6.3005
R2322 VDD.n150 VDD.n92 6.3005
R2323 VDD.n92 VDD.n91 6.3005
R2324 VDD.n156 VDD.n155 6.3005
R2325 VDD.n157 VDD.n156 6.3005
R2326 VDD.n154 VDD.n88 6.3005
R2327 VDD.n89 VDD.n88 6.3005
R2328 VDD.n163 VDD.n162 6.3005
R2329 VDD.n162 VDD.n161 6.3005
R2330 VDD.n164 VDD.n87 6.3005
R2331 VDD.n87 VDD.n86 6.3005
R2332 VDD.n167 VDD.n166 6.3005
R2333 VDD.n301 VDD.n300 6.3005
R2334 VDD.n298 VDD.n221 6.3005
R2335 VDD.n221 VDD.n220 6.3005
R2336 VDD.n297 VDD.n296 6.3005
R2337 VDD.n296 VDD.n295 6.3005
R2338 VDD.n288 VDD.n222 6.3005
R2339 VDD.n223 VDD.n222 6.3005
R2340 VDD.n290 VDD.n289 6.3005
R2341 VDD.n291 VDD.n290 6.3005
R2342 VDD.n284 VDD.n226 6.3005
R2343 VDD.n226 VDD.n225 6.3005
R2344 VDD.n283 VDD.n282 6.3005
R2345 VDD.n282 VDD.n281 6.3005
R2346 VDD.n273 VDD.n228 6.3005
R2347 VDD.n229 VDD.n228 6.3005
R2348 VDD.n276 VDD.n275 6.3005
R2349 VDD.n277 VDD.n276 6.3005
R2350 VDD.n272 VDD.n232 6.3005
R2351 VDD.n232 VDD.n231 6.3005
R2352 VDD.n271 VDD.n270 6.3005
R2353 VDD.n270 VDD.n269 6.3005
R2354 VDD.n262 VDD.n233 6.3005
R2355 VDD.n234 VDD.n233 6.3005
R2356 VDD.n264 VDD.n263 6.3005
R2357 VDD.n265 VDD.n264 6.3005
R2358 VDD.n257 VDD.n237 6.3005
R2359 VDD.n237 VDD.n236 6.3005
R2360 VDD.n256 VDD.n255 6.3005
R2361 VDD.n255 VDD.n254 6.3005
R2362 VDD.n247 VDD.n239 6.3005
R2363 VDD.n240 VDD.n239 6.3005
R2364 VDD.n249 VDD.n248 6.3005
R2365 VDD.n250 VDD.n249 6.3005
R2366 VDD.n246 VDD.n243 6.3005
R2367 VDD.n243 VDD.n242 6.3005
R2368 VDD.n477 VDD.n20 5.6305
R2369 VDD.n407 VDD.t437 5.54817
R2370 VDD.n474 VDD.t260 5.54817
R2371 VDD.n45 VDD.t372 5.54817
R2372 VDD.n82 VDD.t471 5.54817
R2373 VDD.n545 VDD.n544 5.54261
R2374 VDD.n407 VDD.n406 5.51014
R2375 VDD.n415 VDD.n413 5.51014
R2376 VDD.n420 VDD.n418 5.51014
R2377 VDD.n424 VDD.n422 5.51014
R2378 VDD.n434 VDD.n432 5.51014
R2379 VDD.n316 VDD.n314 5.51014
R2380 VDD.n311 VDD.n309 5.51014
R2381 VDD.n451 VDD.n449 5.51014
R2382 VDD.n460 VDD.n458 5.51014
R2383 VDD.n306 VDD.n304 5.51014
R2384 VDD.n474 VDD.n473 5.51014
R2385 VDD.n45 VDD.n44 5.51014
R2386 VDD.n212 VDD.n211 5.51014
R2387 VDD.n50 VDD.n48 5.51014
R2388 VDD.n204 VDD.n202 5.51014
R2389 VDD.n199 VDD.n198 5.51014
R2390 VDD.n188 VDD.n187 5.51014
R2391 VDD.n184 VDD.n183 5.51014
R2392 VDD.n68 VDD.n66 5.51014
R2393 VDD.n79 VDD.n78 5.51014
R2394 VDD.n176 VDD.n175 5.51014
R2395 VDD.n82 VDD.n81 5.51014
R2396 VDD.n502 VDD.n500 5.51014
R2397 VDD.n506 VDD.n504 5.51014
R2398 VDD.n519 VDD.n517 5.51014
R2399 VDD.n497 VDD.n495 5.51014
R2400 VDD.n529 VDD.n527 5.51014
R2401 VDD.n482 VDD.n480 5.51014
R2402 VDD.n486 VDD.n484 5.51014
R2403 VDD.n552 VDD.n550 5.51014
R2404 VDD.n567 VDD.n565 5.51014
R2405 VDD.n575 VDD.n573 5.51014
R2406 VDD.n585 VDD.n583 5.51014
R2407 VDD.n456 VDD.n455 5.43909
R2408 VDD.n61 VDD.n59 5.43909
R2409 VDD.n456 VDD.n454 5.39172
R2410 VDD.n61 VDD.n60 5.39172
R2411 VDD.n415 VDD.n414 5.32067
R2412 VDD.n420 VDD.n419 5.32067
R2413 VDD.n424 VDD.n423 5.32067
R2414 VDD.n426 VDD.n425 5.32067
R2415 VDD.n428 VDD.n427 5.32067
R2416 VDD.n430 VDD.n429 5.32067
R2417 VDD.n434 VDD.n433 5.32067
R2418 VDD.n316 VDD.n315 5.32067
R2419 VDD.n311 VDD.n310 5.32067
R2420 VDD.n451 VDD.n450 5.32067
R2421 VDD.n460 VDD.n459 5.32067
R2422 VDD.n462 VDD.n461 5.32067
R2423 VDD.n464 VDD.n463 5.32067
R2424 VDD.n466 VDD.n465 5.32067
R2425 VDD.n306 VDD.n305 5.32067
R2426 VDD.n212 VDD.n210 5.32067
R2427 VDD.n56 VDD.n55 5.32067
R2428 VDD.n54 VDD.n53 5.32067
R2429 VDD.n52 VDD.n51 5.32067
R2430 VDD.n50 VDD.n49 5.32067
R2431 VDD.n204 VDD.n203 5.32067
R2432 VDD.n199 VDD.n197 5.32067
R2433 VDD.n188 VDD.n186 5.32067
R2434 VDD.n184 VDD.n182 5.32067
R2435 VDD.n74 VDD.n73 5.32067
R2436 VDD.n72 VDD.n71 5.32067
R2437 VDD.n70 VDD.n69 5.32067
R2438 VDD.n68 VDD.n67 5.32067
R2439 VDD.n79 VDD.n77 5.32067
R2440 VDD.n176 VDD.n174 5.32067
R2441 VDD.n502 VDD.n501 5.32067
R2442 VDD.n510 VDD.n509 5.32067
R2443 VDD.n508 VDD.n507 5.32067
R2444 VDD.n506 VDD.n505 5.32067
R2445 VDD.n516 VDD.n515 5.32067
R2446 VDD.n521 VDD.n520 5.32067
R2447 VDD.n519 VDD.n518 5.32067
R2448 VDD.n497 VDD.n496 5.32067
R2449 VDD.n538 VDD.n537 5.32067
R2450 VDD.n540 VDD.n539 5.32067
R2451 VDD.n542 VDD.n541 5.32067
R2452 VDD.n544 VDD.n543 5.32067
R2453 VDD.n533 VDD.n532 5.32067
R2454 VDD.n531 VDD.n530 5.32067
R2455 VDD.n529 VDD.n528 5.32067
R2456 VDD.n482 VDD.n481 5.32067
R2457 VDD.n490 VDD.n489 5.32067
R2458 VDD.n488 VDD.n487 5.32067
R2459 VDD.n486 VDD.n485 5.32067
R2460 VDD.n556 VDD.n555 5.32067
R2461 VDD.n554 VDD.n553 5.32067
R2462 VDD.n552 VDD.n551 5.32067
R2463 VDD.n564 VDD.n563 5.32067
R2464 VDD.n569 VDD.n568 5.32067
R2465 VDD.n567 VDD.n566 5.32067
R2466 VDD.n579 VDD.n578 5.32067
R2467 VDD.n577 VDD.n576 5.32067
R2468 VDD.n575 VDD.n574 5.32067
R2469 VDD.n585 VDD.n584 5.32067
R2470 VDD.n587 VDD.n586 5.28208
R2471 VDD.n536 VDD.n535 5.08746
R2472 VDD.n558 VDD.n492 5.08746
R2473 VDD.n498 VDD.n497 5.02155
R2474 VDD.n538 VDD.n536 4.68997
R2475 VDD.n483 VDD.n482 4.54787
R2476 VDD.n446 VDD.n445 4.5005
R2477 VDD.n472 VDD.n303 4.5005
R2478 VDD.n471 VDD.n470 4.5005
R2479 VDD.n469 VDD.n468 4.5005
R2480 VDD.n453 VDD.n308 4.5005
R2481 VDD.n448 VDD.n447 4.5005
R2482 VDD.n442 VDD.n313 4.5005
R2483 VDD.n439 VDD.n438 4.5005
R2484 VDD.n437 VDD.n436 4.5005
R2485 VDD.n417 VDD.n318 4.5005
R2486 VDD.n412 VDD.n411 4.5005
R2487 VDD.n410 VDD.n319 4.5005
R2488 VDD.n172 VDD.n171 4.5005
R2489 VDD.n173 VDD.n76 4.5005
R2490 VDD.n179 VDD.n178 4.5005
R2491 VDD.n181 VDD.n180 4.5005
R2492 VDD.n190 VDD.n65 4.5005
R2493 VDD.n194 VDD.n193 4.5005
R2494 VDD.n196 VDD.n195 4.5005
R2495 VDD.n201 VDD.n58 4.5005
R2496 VDD.n207 VDD.n206 4.5005
R2497 VDD.n209 VDD.n208 4.5005
R2498 VDD.n214 VDD.n47 4.5005
R2499 VDD.n216 VDD.n215 4.5005
R2500 VDD.n535 VDD.n534 4.5005
R2501 VDD.n558 VDD.n557 4.5005
R2502 VDD.n492 VDD.n491 4.5005
R2503 VDD.n588 VDD.n587 4.4605
R2504 VDD.n548 VDD.n546 3.26892
R2505 VDD.n27 VDD.n23 3.1805
R2506 VDD.n476 VDD.n475 3.13687
R2507 VDD.n217 VDD.n46 3.13687
R2508 VDD.n42 VDD.n38 3.0962
R2509 VDD.n587 VDD.n477 2.7705
R2510 VDD.n590 VDD.n27 2.5955
R2511 VDD.n409 VDD.n408 2.5452
R2512 VDD.n170 VDD.n83 2.5452
R2513 VDD.n26 VDD.n24 2.28717
R2514 VDD.n41 VDD.n39 2.26494
R2515 VDD.n42 VDD.n41 2.20416
R2516 VDD.n545 VDD.n498 1.95702
R2517 VDD.n589 VDD.n588 1.8805
R2518 VDD.n546 VDD.n493 1.8005
R2519 VDD.n589 VDD.n43 1.69099
R2520 VDD.n562 VDD.n561 1.61103
R2521 VDD.n586 VDD.n582 1.51629
R2522 VDD.n561 VDD.n559 1.42155
R2523 VDD.n514 VDD.n513 1.42155
R2524 VDD.n359 VDD.n358 1.26366
R2525 VDD.n358 VDD.n335 1.26366
R2526 VDD.n389 VDD.n335 1.26366
R2527 VDD.n390 VDD.n389 1.26366
R2528 VDD.n390 VDD.n327 1.26366
R2529 VDD.n327 VDD.n320 1.26366
R2530 VDD.n153 VDD.n84 1.26366
R2531 VDD.n153 VDD.n152 1.26366
R2532 VDD.n152 VDD.n93 1.26366
R2533 VDD.n126 VDD.n93 1.26366
R2534 VDD.n126 VDD.n125 1.26366
R2535 VDD.n125 VDD.n104 1.26366
R2536 VDD.n287 VDD.n286 1.26366
R2537 VDD.n286 VDD.n227 1.26366
R2538 VDD.n260 VDD.n227 1.26366
R2539 VDD.n260 VDD.n259 1.26366
R2540 VDD.n259 VDD.n238 1.26366
R2541 VDD.n572 VDD.n571 1.23208
R2542 VDD.n287 VDD.n218 1.21103
R2543 VDD.n525 VDD.n523 1.13734
R2544 VDD.n549 VDD.n548 1.08997
R2545 VDD.n29 VDD.n28 1.03676
R2546 VDD.n368 VDD.n367 1.0005
R2547 VDD.n368 VDD.n354 1.0005
R2548 VDD.n374 VDD.n354 1.0005
R2549 VDD.n375 VDD.n374 1.0005
R2550 VDD.n376 VDD.n375 1.0005
R2551 VDD.n376 VDD.n346 1.0005
R2552 VDD.n383 VDD.n346 1.0005
R2553 VDD.n384 VDD.n383 1.0005
R2554 VDD.n385 VDD.n384 1.0005
R2555 VDD.n385 VDD.n340 1.0005
R2556 VDD.n340 VDD.n333 1.0005
R2557 VDD.n394 VDD.n333 1.0005
R2558 VDD.n395 VDD.n394 1.0005
R2559 VDD.n396 VDD.n395 1.0005
R2560 VDD.n396 VDD.n323 1.0005
R2561 VDD.n402 VDD.n323 1.0005
R2562 VDD.n402 VDD.n321 1.0005
R2563 VDD.n167 VDD.n86 1.0005
R2564 VDD.n161 VDD.n86 1.0005
R2565 VDD.n161 VDD.n89 1.0005
R2566 VDD.n157 VDD.n89 1.0005
R2567 VDD.n157 VDD.n91 1.0005
R2568 VDD.n147 VDD.n91 1.0005
R2569 VDD.n147 VDD.n95 1.0005
R2570 VDD.n143 VDD.n95 1.0005
R2571 VDD.n143 VDD.n97 1.0005
R2572 VDD.n135 VDD.n97 1.0005
R2573 VDD.n135 VDD.n100 1.0005
R2574 VDD.n131 VDD.n100 1.0005
R2575 VDD.n131 VDD.n102 1.0005
R2576 VDD.n120 VDD.n102 1.0005
R2577 VDD.n120 VDD.n107 1.0005
R2578 VDD.n116 VDD.n107 1.0005
R2579 VDD.n116 VDD.n109 1.0005
R2580 VDD.n301 VDD.n220 1.0005
R2581 VDD.n295 VDD.n220 1.0005
R2582 VDD.n295 VDD.n223 1.0005
R2583 VDD.n291 VDD.n223 1.0005
R2584 VDD.n291 VDD.n225 1.0005
R2585 VDD.n281 VDD.n225 1.0005
R2586 VDD.n281 VDD.n229 1.0005
R2587 VDD.n277 VDD.n229 1.0005
R2588 VDD.n277 VDD.n231 1.0005
R2589 VDD.n269 VDD.n231 1.0005
R2590 VDD.n269 VDD.n234 1.0005
R2591 VDD.n265 VDD.n234 1.0005
R2592 VDD.n265 VDD.n236 1.0005
R2593 VDD.n254 VDD.n236 1.0005
R2594 VDD.n254 VDD.n240 1.0005
R2595 VDD.n250 VDD.n240 1.0005
R2596 VDD.n250 VDD.n242 1.0005
R2597 VDD.n526 VDD.n525 0.947868
R2598 VDD.n472 VDD.n471 0.9005
R2599 VDD.n412 VDD.n319 0.9005
R2600 VDD.n173 VDD.n172 0.9005
R2601 VDD.n215 VDD.n214 0.9005
R2602 VDD.n444 VDD.n442 0.8855
R2603 VDD.n193 VDD.n64 0.8855
R2604 VDD.n43 VDD.n30 0.884153
R2605 VDD.n471 VDD.n307 0.8405
R2606 VDD.n214 VDD.n213 0.8405
R2607 VDD.n445 VDD.n312 0.8105
R2608 VDD.n200 VDD.n196 0.8105
R2609 VDD.n4 VDD.n3 0.8005
R2610 VDD.n7 VDD.n2 0.8005
R2611 VDD.n9 VDD.n8 0.8005
R2612 VDD.n12 VDD.n1 0.8005
R2613 VDD.n14 VDD.n13 0.8005
R2614 VDD.n17 VDD.n0 0.8005
R2615 VDD.n435 VDD.n317 0.7505
R2616 VDD.n189 VDD.n185 0.7505
R2617 VDD.n43 VDD.n42 0.745997
R2618 VDD.n452 VDD.n448 0.7355
R2619 VDD.n205 VDD.n201 0.7355
R2620 VDD.n23 VDD.n22 0.7005
R2621 VDD.n416 VDD.n412 0.6605
R2622 VDD.n177 VDD.n173 0.6605
R2623 VDD.n467 VDD.n457 0.622051
R2624 VDD.n62 VDD.n57 0.622051
R2625 VDD.n441 VDD.n439 0.5855
R2626 VDD.n192 VDD.n190 0.5855
R2627 VDD.n549 VDD.n478 0.568921
R2628 VDD.n421 VDD.n417 0.5105
R2629 VDD.n178 VDD.n80 0.5105
R2630 VDD.n27 VDD.n26 0.507167
R2631 VDD.n367 VDD.n366 0.481712
R2632 VDD.n109 VDD.n108 0.481712
R2633 VDD.n242 VDD.n241 0.481712
R2634 VDD.n526 VDD.n493 0.474184
R2635 VDD.n34 VDD.n33 0.451962
R2636 VDD.n363 VDD.n362 0.444944
R2637 VDD.n362 VDD.n353 0.444944
R2638 VDD.n353 VDD.n352 0.444944
R2639 VDD.n352 VDD.n351 0.444944
R2640 VDD.n351 VDD.n350 0.444944
R2641 VDD.n350 VDD.n345 0.444944
R2642 VDD.n345 VDD.n344 0.444944
R2643 VDD.n344 VDD.n343 0.444944
R2644 VDD.n343 VDD.n342 0.444944
R2645 VDD.n342 VDD.n341 0.444944
R2646 VDD.n341 VDD.n332 0.444944
R2647 VDD.n332 VDD.n331 0.444944
R2648 VDD.n331 VDD.n330 0.444944
R2649 VDD.n330 VDD.n322 0.444944
R2650 VDD.n403 VDD.n322 0.444944
R2651 VDD.n160 VDD.n85 0.444944
R2652 VDD.n160 VDD.n159 0.444944
R2653 VDD.n159 VDD.n158 0.444944
R2654 VDD.n158 VDD.n90 0.444944
R2655 VDD.n146 VDD.n90 0.444944
R2656 VDD.n146 VDD.n145 0.444944
R2657 VDD.n145 VDD.n144 0.444944
R2658 VDD.n144 VDD.n96 0.444944
R2659 VDD.n134 VDD.n96 0.444944
R2660 VDD.n134 VDD.n133 0.444944
R2661 VDD.n133 VDD.n132 0.444944
R2662 VDD.n132 VDD.n101 0.444944
R2663 VDD.n119 VDD.n101 0.444944
R2664 VDD.n119 VDD.n118 0.444944
R2665 VDD.n118 VDD.n117 0.444944
R2666 VDD.n294 VDD.n219 0.444944
R2667 VDD.n294 VDD.n293 0.444944
R2668 VDD.n293 VDD.n292 0.444944
R2669 VDD.n292 VDD.n224 0.444944
R2670 VDD.n280 VDD.n224 0.444944
R2671 VDD.n280 VDD.n279 0.444944
R2672 VDD.n279 VDD.n278 0.444944
R2673 VDD.n278 VDD.n230 0.444944
R2674 VDD.n268 VDD.n230 0.444944
R2675 VDD.n268 VDD.n267 0.444944
R2676 VDD.n267 VDD.n266 0.444944
R2677 VDD.n266 VDD.n235 0.444944
R2678 VDD.n253 VDD.n235 0.444944
R2679 VDD.n253 VDD.n252 0.444944
R2680 VDD.n252 VDD.n251 0.444944
R2681 VDD.n588 VDD.n217 0.423149
R2682 VDD.n477 VDD.n476 0.393149
R2683 VDD.n559 VDD.n478 0.379447
R2684 VDD.n32 VDD.n31 0.356056
R2685 VDD.n33 VDD.n32 0.356056
R2686 VDD.n30 VDD.n29 0.337342
R2687 VDD.n442 VDD.n441 0.3155
R2688 VDD.n193 VDD.n192 0.3155
R2689 VDD.n404 VDD.n403 0.311611
R2690 VDD.n168 VDD.n85 0.311611
R2691 VDD.n436 VDD.n431 0.256124
R2692 VDD.n181 VDD.n75 0.256124
R2693 VDD.n417 VDD.n416 0.2405
R2694 VDD.n178 VDD.n177 0.2405
R2695 VDD.n26 VDD.n25 0.238278
R2696 VDD.n406 VDD.t141 0.228
R2697 VDD.n406 VDD.t139 0.228
R2698 VDD.n413 VDD.t251 0.228
R2699 VDD.n413 VDD.t258 0.228
R2700 VDD.n414 VDD.t255 0.228
R2701 VDD.n414 VDD.t253 0.228
R2702 VDD.n418 VDD.t475 0.228
R2703 VDD.n418 VDD.t473 0.228
R2704 VDD.n419 VDD.t24 0.228
R2705 VDD.n419 VDD.t22 0.228
R2706 VDD.n422 VDD.t235 0.228
R2707 VDD.n422 VDD.t237 0.228
R2708 VDD.n423 VDD.t231 0.228
R2709 VDD.n423 VDD.t233 0.228
R2710 VDD.n425 VDD.t227 0.228
R2711 VDD.n425 VDD.t229 0.228
R2712 VDD.n427 VDD.t223 0.228
R2713 VDD.n427 VDD.t225 0.228
R2714 VDD.n429 VDD.t219 0.228
R2715 VDD.n429 VDD.t221 0.228
R2716 VDD.n432 VDD.t352 0.228
R2717 VDD.n432 VDD.t350 0.228
R2718 VDD.n433 VDD.t136 0.228
R2719 VDD.n433 VDD.t134 0.228
R2720 VDD.n314 VDD.t215 0.228
R2721 VDD.n314 VDD.t217 0.228
R2722 VDD.n315 VDD.t213 0.228
R2723 VDD.n315 VDD.t211 0.228
R2724 VDD.n440 VDD.t52 0.228
R2725 VDD.n440 VDD.t50 0.228
R2726 VDD.n443 VDD.t4 0.228
R2727 VDD.n443 VDD.t2 0.228
R2728 VDD.n309 VDD.t195 0.228
R2729 VDD.n309 VDD.t201 0.228
R2730 VDD.n310 VDD.t197 0.228
R2731 VDD.n310 VDD.t199 0.228
R2732 VDD.n449 VDD.t430 0.228
R2733 VDD.n449 VDD.t428 0.228
R2734 VDD.n450 VDD.t163 0.228
R2735 VDD.n450 VDD.t161 0.228
R2736 VDD.n454 VDD.t449 0.228
R2737 VDD.n454 VDD.t447 0.228
R2738 VDD.n455 VDD.t268 0.228
R2739 VDD.n455 VDD.t266 0.228
R2740 VDD.n458 VDD.t185 0.228
R2741 VDD.n458 VDD.t193 0.228
R2742 VDD.n459 VDD.t189 0.228
R2743 VDD.n459 VDD.t191 0.228
R2744 VDD.n461 VDD.t175 0.228
R2745 VDD.n461 VDD.t187 0.228
R2746 VDD.n463 VDD.t181 0.228
R2747 VDD.n463 VDD.t183 0.228
R2748 VDD.n465 VDD.t177 0.228
R2749 VDD.n465 VDD.t179 0.228
R2750 VDD.n304 VDD.t441 0.228
R2751 VDD.n304 VDD.t439 0.228
R2752 VDD.n305 VDD.t382 0.228
R2753 VDD.n305 VDD.t380 0.228
R2754 VDD.n473 VDD.t398 0.228
R2755 VDD.n473 VDD.t396 0.228
R2756 VDD.n44 VDD.t392 0.228
R2757 VDD.n44 VDD.t390 0.228
R2758 VDD.n210 VDD.t465 0.228
R2759 VDD.n210 VDD.t169 0.228
R2760 VDD.n211 VDD.t469 0.228
R2761 VDD.n211 VDD.t467 0.228
R2762 VDD.n55 VDD.t330 0.228
R2763 VDD.n55 VDD.t332 0.228
R2764 VDD.n53 VDD.t326 0.228
R2765 VDD.n53 VDD.t328 0.228
R2766 VDD.n51 VDD.t322 0.228
R2767 VDD.n51 VDD.t324 0.228
R2768 VDD.n49 VDD.t318 0.228
R2769 VDD.n49 VDD.t320 0.228
R2770 VDD.n48 VDD.t314 0.228
R2771 VDD.n48 VDD.t316 0.228
R2772 VDD.n59 VDD.t102 0.228
R2773 VDD.n59 VDD.t400 0.228
R2774 VDD.n60 VDD.t106 0.228
R2775 VDD.n60 VDD.t104 0.228
R2776 VDD.n203 VDD.t483 0.228
R2777 VDD.n203 VDD.t481 0.228
R2778 VDD.n202 VDD.t240 0.228
R2779 VDD.n202 VDD.t485 0.228
R2780 VDD.n197 VDD.t306 0.228
R2781 VDD.n197 VDD.t312 0.228
R2782 VDD.n198 VDD.t308 0.228
R2783 VDD.n198 VDD.t310 0.228
R2784 VDD.n63 VDD.t244 0.228
R2785 VDD.n63 VDD.t242 0.228
R2786 VDD.n191 VDD.t386 0.228
R2787 VDD.n191 VDD.t384 0.228
R2788 VDD.n186 VDD.t296 0.228
R2789 VDD.n186 VDD.t274 0.228
R2790 VDD.n187 VDD.t270 0.228
R2791 VDD.n187 VDD.t272 0.228
R2792 VDD.n182 VDD.t374 0.228
R2793 VDD.n182 VDD.t388 0.228
R2794 VDD.n183 VDD.t378 0.228
R2795 VDD.n183 VDD.t376 0.228
R2796 VDD.n73 VDD.t294 0.228
R2797 VDD.n73 VDD.t282 0.228
R2798 VDD.n71 VDD.t292 0.228
R2799 VDD.n71 VDD.t276 0.228
R2800 VDD.n69 VDD.t290 0.228
R2801 VDD.n69 VDD.t284 0.228
R2802 VDD.n67 VDD.t286 0.228
R2803 VDD.n67 VDD.t288 0.228
R2804 VDD.n66 VDD.t278 0.228
R2805 VDD.n66 VDD.t280 0.228
R2806 VDD.n77 VDD.t487 0.228
R2807 VDD.n77 VDD.t172 0.228
R2808 VDD.n78 VDD.t491 0.228
R2809 VDD.n78 VDD.t489 0.228
R2810 VDD.n174 VDD.t342 0.228
R2811 VDD.n174 VDD.t394 0.228
R2812 VDD.n175 VDD.t346 0.228
R2813 VDD.n175 VDD.t344 0.228
R2814 VDD.n81 VDD.t152 0.228
R2815 VDD.n81 VDD.t150 0.228
R2816 VDD.n501 VDD.t455 0.228
R2817 VDD.n501 VDD.t402 0.228
R2818 VDD.n500 VDD.t348 0.228
R2819 VDD.n500 VDD.t453 0.228
R2820 VDD.n511 VDD.t137 0.228
R2821 VDD.n511 VDD.t155 0.228
R2822 VDD.n509 VDD.t44 0.228
R2823 VDD.n509 VDD.t46 0.228
R2824 VDD.n507 VDD.t40 0.228
R2825 VDD.n507 VDD.t42 0.228
R2826 VDD.n505 VDD.t36 0.228
R2827 VDD.n505 VDD.t38 0.228
R2828 VDD.n504 VDD.t32 0.228
R2829 VDD.n504 VDD.t34 0.228
R2830 VDD.n515 VDD.t76 0.228
R2831 VDD.n515 VDD.t78 0.228
R2832 VDD.n520 VDD.t72 0.228
R2833 VDD.n520 VDD.t74 0.228
R2834 VDD.n518 VDD.t68 0.228
R2835 VDD.n518 VDD.t70 0.228
R2836 VDD.n517 VDD.t64 0.228
R2837 VDD.n517 VDD.t66 0.228
R2838 VDD.n524 VDD.t159 0.228
R2839 VDD.n524 VDD.t158 0.228
R2840 VDD.n499 VDD.t154 0.228
R2841 VDD.n499 VDD.t153 0.228
R2842 VDD.n494 VDD.t167 0.228
R2843 VDD.n494 VDD.t165 0.228
R2844 VDD.n495 VDD.t445 0.228
R2845 VDD.n495 VDD.t457 0.228
R2846 VDD.n496 VDD.t354 0.228
R2847 VDD.n496 VDD.t404 0.228
R2848 VDD.n537 VDD.t120 0.228
R2849 VDD.n537 VDD.t122 0.228
R2850 VDD.n539 VDD.t110 0.228
R2851 VDD.n539 VDD.t118 0.228
R2852 VDD.n541 VDD.t114 0.228
R2853 VDD.n541 VDD.t108 0.228
R2854 VDD.n543 VDD.t112 0.228
R2855 VDD.n543 VDD.t116 0.228
R2856 VDD.n532 VDD.t129 0.228
R2857 VDD.n532 VDD.t130 0.228
R2858 VDD.n530 VDD.t127 0.228
R2859 VDD.n530 VDD.t128 0.228
R2860 VDD.n528 VDD.t125 0.228
R2861 VDD.n528 VDD.t126 0.228
R2862 VDD.n527 VDD.t123 0.228
R2863 VDD.n527 VDD.t124 0.228
R2864 VDD.n547 VDD.t461 0.228
R2865 VDD.n547 VDD.t459 0.228
R2866 VDD.n479 VDD.t264 0.228
R2867 VDD.n479 VDD.t262 0.228
R2868 VDD.n481 VDD.t145 0.228
R2869 VDD.n481 VDD.t62 0.228
R2870 VDD.n480 VDD.t451 0.228
R2871 VDD.n480 VDD.t143 0.228
R2872 VDD.n489 VDD.t425 0.228
R2873 VDD.n489 VDD.t426 0.228
R2874 VDD.n487 VDD.t424 0.228
R2875 VDD.n487 VDD.t412 0.228
R2876 VDD.n485 VDD.t423 0.228
R2877 VDD.n485 VDD.t413 0.228
R2878 VDD.n484 VDD.t422 0.228
R2879 VDD.n484 VDD.t415 0.228
R2880 VDD.n555 VDD.t410 0.228
R2881 VDD.n555 VDD.t406 0.228
R2882 VDD.n553 VDD.t419 0.228
R2883 VDD.n553 VDD.t421 0.228
R2884 VDD.n551 VDD.t408 0.228
R2885 VDD.n551 VDD.t420 0.228
R2886 VDD.n550 VDD.t417 0.228
R2887 VDD.n550 VDD.t418 0.228
R2888 VDD.n560 VDD.t340 0.228
R2889 VDD.n560 VDD.t339 0.228
R2890 VDD.n563 VDD.t81 0.228
R2891 VDD.n563 VDD.t95 0.228
R2892 VDD.n568 VDD.t91 0.228
R2893 VDD.n568 VDD.t93 0.228
R2894 VDD.n566 VDD.t85 0.228
R2895 VDD.n566 VDD.t89 0.228
R2896 VDD.n565 VDD.t87 0.228
R2897 VDD.n565 VDD.t83 0.228
R2898 VDD.n580 VDD.t477 0.228
R2899 VDD.n580 VDD.t476 0.228
R2900 VDD.n578 VDD.t362 0.228
R2901 VDD.n578 VDD.t370 0.228
R2902 VDD.n576 VDD.t358 0.228
R2903 VDD.n576 VDD.t368 0.228
R2904 VDD.n574 VDD.t364 0.228
R2905 VDD.n574 VDD.t356 0.228
R2906 VDD.n573 VDD.t360 0.228
R2907 VDD.n573 VDD.t366 0.228
R2908 VDD.n584 VDD.t26 0.228
R2909 VDD.n584 VDD.t157 0.228
R2910 VDD.n583 VDD.t463 0.228
R2911 VDD.n583 VDD.t443 0.228
R2912 VDD.n41 VDD.n40 0.227751
R2913 VDD.n405 VDD.n320 0.191026
R2914 VDD.n169 VDD.n84 0.191026
R2915 VDD.n430 VDD.n428 0.189974
R2916 VDD.n428 VDD.n426 0.189974
R2917 VDD.n426 VDD.n424 0.189974
R2918 VDD.n466 VDD.n464 0.189974
R2919 VDD.n464 VDD.n462 0.189974
R2920 VDD.n462 VDD.n460 0.189974
R2921 VDD.n52 VDD.n50 0.189974
R2922 VDD.n54 VDD.n52 0.189974
R2923 VDD.n56 VDD.n54 0.189974
R2924 VDD.n70 VDD.n68 0.189974
R2925 VDD.n72 VDD.n70 0.189974
R2926 VDD.n74 VDD.n72 0.189974
R2927 VDD.n508 VDD.n506 0.189974
R2928 VDD.n510 VDD.n508 0.189974
R2929 VDD.n521 VDD.n519 0.189974
R2930 VDD.n531 VDD.n529 0.189974
R2931 VDD.n533 VDD.n531 0.189974
R2932 VDD.n534 VDD.n533 0.189974
R2933 VDD.n544 VDD.n542 0.189974
R2934 VDD.n542 VDD.n540 0.189974
R2935 VDD.n540 VDD.n538 0.189974
R2936 VDD.n554 VDD.n552 0.189974
R2937 VDD.n556 VDD.n554 0.189974
R2938 VDD.n557 VDD.n556 0.189974
R2939 VDD.n488 VDD.n486 0.189974
R2940 VDD.n490 VDD.n488 0.189974
R2941 VDD.n491 VDD.n490 0.189974
R2942 VDD.n569 VDD.n567 0.189974
R2943 VDD.n577 VDD.n575 0.189974
R2944 VDD.n579 VDD.n577 0.189974
R2945 VDD.n410 VDD.n409 0.185206
R2946 VDD.n171 VDD.n170 0.185206
R2947 VDD.n35 VDD.n34 0.168921
R2948 VDD.n36 VDD.n35 0.168921
R2949 VDD.n37 VDD.n36 0.168921
R2950 VDD.n453 VDD.n452 0.1655
R2951 VDD.n408 VDD.n319 0.1655
R2952 VDD.n172 VDD.n83 0.1655
R2953 VDD.n206 VDD.n205 0.1655
R2954 VDD.n476 VDD.n303 0.15819
R2955 VDD.n217 VDD.n216 0.15819
R2956 VDD.n468 VDD.n467 0.143825
R2957 VDD.n209 VDD.n57 0.143825
R2958 VDD.n475 VDD.n472 0.1355
R2959 VDD.n457 VDD.n453 0.1355
R2960 VDD.n206 VDD.n62 0.1355
R2961 VDD.n215 VDD.n46 0.1355
R2962 VDD.n431 VDD.n421 0.135448
R2963 VDD.n80 VDD.n75 0.135448
R2964 VDD.n302 VDD.n219 0.133833
R2965 VDD.n590 VDD.n589 0.1265
R2966 VDD.n470 VDD.n303 0.1205
R2967 VDD.n470 VDD.n469 0.1205
R2968 VDD.n469 VDD.n308 0.1205
R2969 VDD.n447 VDD.n308 0.1205
R2970 VDD.n447 VDD.n446 0.1205
R2971 VDD.n446 VDD.n313 0.1205
R2972 VDD.n438 VDD.n313 0.1205
R2973 VDD.n438 VDD.n437 0.1205
R2974 VDD.n437 VDD.n318 0.1205
R2975 VDD.n411 VDD.n318 0.1205
R2976 VDD.n411 VDD.n410 0.1205
R2977 VDD.n171 VDD.n76 0.1205
R2978 VDD.n179 VDD.n76 0.1205
R2979 VDD.n180 VDD.n179 0.1205
R2980 VDD.n180 VDD.n65 0.1205
R2981 VDD.n194 VDD.n65 0.1205
R2982 VDD.n195 VDD.n194 0.1205
R2983 VDD.n195 VDD.n58 0.1205
R2984 VDD.n207 VDD.n58 0.1205
R2985 VDD.n208 VDD.n207 0.1205
R2986 VDD.n208 VDD.n47 0.1205
R2987 VDD.n216 VDD.n47 0.1205
R2988 VDD.n591 VDD.n20 0.1105
R2989 VDD.n4 VDD.n2 0.1005
R2990 VDD.n8 VDD.n7 0.1005
R2991 VDD.n9 VDD.n1 0.1005
R2992 VDD.n13 VDD.n12 0.1005
R2993 VDD.n14 VDD.n0 0.1005
R2994 VDD.n18 VDD.n17 0.1005
R2995 VDD.n23 VDD.n21 0.1005
R2996 VDD.n582 VDD.n572 0.0952368
R2997 VDD.n571 VDD.n562 0.0952368
R2998 VDD.n523 VDD.n514 0.0952368
R2999 VDD.n513 VDD.n503 0.0952368
R3000 VDD.n522 VDD.n521 0.0952368
R3001 VDD.n522 VDD.n516 0.0952368
R3002 VDD.n570 VDD.n569 0.0952368
R3003 VDD.n570 VDD.n564 0.0952368
R3004 VDD.n448 VDD.n312 0.0905
R3005 VDD.n439 VDD.n317 0.0905
R3006 VDD.n190 VDD.n189 0.0905
R3007 VDD.n201 VDD.n200 0.0905
R3008 VDD.n38 VDD.n37 0.0678684
R3009 VDD.n468 VDD.n307 0.0605
R3010 VDD.n436 VDD.n435 0.0605
R3011 VDD.n185 VDD.n181 0.0605
R3012 VDD.n213 VDD.n209 0.0605
R3013 VDD.n405 VDD.n404 0.0505
R3014 VDD.n169 VDD.n168 0.0505
R3015 VDD.n587 VDD.n302 0.0505
R3016 VDD.n409 VDD.n405 0.0452248
R3017 VDD.n170 VDD.n169 0.0452248
R3018 VDD.n587 VDD.n218 0.0331316
R3019 VDD VDD.n591 0.0205
R3020 VDD.n445 VDD.n444 0.0155
R3021 VDD.n196 VDD.n64 0.0155
R3022 VSS.n1493 VSS.n8 123500
R3023 VSS.n1293 VSS.t511 48139.4
R3024 VSS.n1294 VSS.n1293 47272.7
R3025 VSS.n1493 VSS.n1492 10017.1
R3026 VSS.n1292 VSS.n204 5590
R3027 VSS.n596 VSS.n8 5225.57
R3028 VSS.n1537 VSS.n35 4239.13
R3029 VSS.n1271 VSS.n273 3801.37
R3030 VSS.t520 VSS.t377 3033.33
R3031 VSS.n1328 VSS.t184 2325.9
R3032 VSS.t377 VSS.t523 1733.33
R3033 VSS.n1284 VSS.n209 1618.73
R3034 VSS.n208 VSS.t520 1462.5
R3035 VSS.t523 VSS.t381 1300
R3036 VSS.n242 VSS.n240 1266.62
R3037 VSS.t511 VSS.n1292 996.668
R3038 VSS.t517 VSS.t376 878.379
R3039 VSS.n242 VSS.n203 780
R3040 VSS.n1303 VSS.n1302 780
R3041 VSS.n1296 VSS.n1295 780
R3042 VSS.n1302 VSS.n181 715
R3043 VSS.n1304 VSS.n1303 651.125
R3044 VSS.n208 VSS.n204 617.5
R3045 VSS.n731 VSS.n730 571.71
R3046 VSS.n1515 VSS.n1514 515.874
R3047 VSS.n1537 VSS.n1536 515.874
R3048 VSS.n1537 VSS.n36 515.874
R3049 VSS.n1556 VSS.n10 515.874
R3050 VSS.n1294 VSS.n203 507
R3051 VSS.t376 VSS.t526 501.932
R3052 VSS.t184 VSS.n1326 465.916
R3053 VSS.n208 VSS.t517 423.505
R3054 VSS.t606 VSS.n1532 392.065
R3055 VSS.n1543 VSS.t252 392.065
R3056 VSS.t526 VSS.t350 376.449
R3057 VSS.t608 VSS.n56 371.43
R3058 VSS.t487 VSS.n1555 371.43
R3059 VSS.t49 VSS.t45 330.159
R3060 VSS.t222 VSS.t201 330.159
R3061 VSS.t11 VSS.n181 330.079
R3062 VSS.n258 VSS.n257 296.139
R3063 VSS.n260 VSS.n259 296.139
R3064 VSS.n263 VSS.n225 296.139
R3065 VSS.n269 VSS.n221 296.139
R3066 VSS.n1276 VSS.n272 296.139
R3067 VSS.n1275 VSS.n1274 296.139
R3068 VSS.n181 VSS.t41 279.298
R3069 VSS.n1296 VSS.n1294 273
R3070 VSS.n52 VSS.t43 268.255
R3071 VSS.n22 VSS.t211 268.255
R3072 VSS.n1521 VSS.t417 247.619
R3073 VSS.n1521 VSS.t145 247.619
R3074 VSS.n1554 VSS.t142 247.619
R3075 VSS.t113 VSS.n1554 247.619
R3076 VSS.n1514 VSS.n1513 237.303
R3077 VSS.n1569 VSS.n10 237.303
R3078 VSS.n1329 VSS.n187 234.94
R3079 VSS.n187 VSS.n181 215.362
R3080 VSS.n1336 VSS.n1335 211.446
R3081 VSS.n1283 VSS.n1282 204.55
R3082 VSS.n1329 VSS.n1328 180.12
R3083 VSS.n209 VSS.n208 178.814
R3084 VSS.n1532 VSS.t602 165.079
R3085 VSS.n1543 VSS.t596 165.079
R3086 VSS.n240 VSS.n239 163.127
R3087 VSS.n56 VSS.t415 144.445
R3088 VSS.t151 VSS.n52 144.445
R3089 VSS.n22 VSS.t136 144.445
R3090 VSS.n1555 VSS.t119 144.445
R3091 VSS.n1304 VSS.n196 134.948
R3092 VSS.n1310 VSS.n196 134.948
R3093 VSS.n1311 VSS.n1310 134.948
R3094 VSS.n1312 VSS.n1311 134.948
R3095 VSS.n1312 VSS.n192 134.948
R3096 VSS.n1318 VSS.n192 134.948
R3097 VSS.n1319 VSS.n1318 134.948
R3098 VSS.n1320 VSS.n1319 134.948
R3099 VSS.n1320 VSS.n188 134.948
R3100 VSS.n1326 VSS.n188 134.948
R3101 VSS.t72 VSS.t489 123.811
R3102 VSS.t592 VSS.t199 123.811
R3103 VSS.n1284 VSS.n1283 116.713
R3104 VSS.n239 VSS.n238 107.915
R3105 VSS.n257 VSS.n226 107.915
R3106 VSS.n261 VSS.n260 107.915
R3107 VSS.n263 VSS.n262 107.915
R3108 VSS.n270 VSS.n269 107.915
R3109 VSS.n272 VSS.n271 107.915
R3110 VSS.n1282 VSS.n212 107.915
R3111 VSS.n596 VSS.n595 91.219
R3112 VSS.n1283 VSS.n211 91.1502
R3113 VSS.n72 VSS.n59 91.0369
R3114 VSS.n1465 VSS.n72 91.0369
R3115 VSS.n789 VSS.n732 91.0369
R3116 VSS.n1560 VSS.n7 87.5005
R3117 VSS.n1562 VSS.n11 87.5005
R3118 VSS.n12 VSS.n11 87.5005
R3119 VSS.n58 VSS.n57 87.5005
R3120 VSS.n57 VSS.n51 87.5005
R3121 VSS.n1522 VSS.n51 87.5005
R3122 VSS.n1522 VSS.n45 87.5005
R3123 VSS.n1526 VSS.n45 87.5005
R3124 VSS.n1526 VSS.n44 87.5005
R3125 VSS.n44 VSS.n39 87.5005
R3126 VSS.n39 VSS.n38 87.5005
R3127 VSS.n38 VSS.n37 87.5005
R3128 VSS.n37 VSS.n30 87.5005
R3129 VSS.n1544 VSS.n30 87.5005
R3130 VSS.n1544 VSS.n24 87.5005
R3131 VSS.n1548 VSS.n24 87.5005
R3132 VSS.n1548 VSS.n23 87.5005
R3133 VSS.n23 VSS.n18 87.5005
R3134 VSS.n18 VSS.n17 87.5005
R3135 VSS.n17 VSS.n16 87.5005
R3136 VSS.n16 VSS.n6 87.5005
R3137 VSS.n1504 VSS.n1503 87.5005
R3138 VSS.n1508 VSS.n1507 87.5005
R3139 VSS.n1516 VSS.n55 87.5005
R3140 VSS.n1516 VSS.n53 87.5005
R3141 VSS.n1520 VSS.n53 87.5005
R3142 VSS.n1520 VSS.n42 87.5005
R3143 VSS.n1527 VSS.n42 87.5005
R3144 VSS.n1527 VSS.n40 87.5005
R3145 VSS.n1531 VSS.n40 87.5005
R3146 VSS.n1531 VSS.n34 87.5005
R3147 VSS.n1538 VSS.n34 87.5005
R3148 VSS.n1538 VSS.n32 87.5005
R3149 VSS.n1542 VSS.n32 87.5005
R3150 VSS.n1542 VSS.n21 87.5005
R3151 VSS.n1549 VSS.n21 87.5005
R3152 VSS.n1549 VSS.n19 87.5005
R3153 VSS.n1553 VSS.n19 87.5005
R3154 VSS.n1553 VSS.n15 87.5005
R3155 VSS.n1557 VSS.n15 87.5005
R3156 VSS.n1557 VSS.n13 87.5005
R3157 VSS.n938 VSS.n422 87.5005
R3158 VSS.n938 VSS.n421 87.5005
R3159 VSS.n904 VSS.n421 87.5005
R3160 VSS.n904 VSS.n433 87.5005
R3161 VSS.n900 VSS.n433 87.5005
R3162 VSS.n900 VSS.n435 87.5005
R3163 VSS.n890 VSS.n435 87.5005
R3164 VSS.n890 VSS.n440 87.5005
R3165 VSS.n886 VSS.n440 87.5005
R3166 VSS.n886 VSS.n442 87.5005
R3167 VSS.n766 VSS.n442 87.5005
R3168 VSS.n776 VSS.n766 87.5005
R3169 VSS.n776 VSS.n764 87.5005
R3170 VSS.n780 VSS.n764 87.5005
R3171 VSS.n780 VSS.n760 87.5005
R3172 VSS.n784 VSS.n760 87.5005
R3173 VSS.n784 VSS.n734 87.5005
R3174 VSS.n788 VSS.n734 87.5005
R3175 VSS.n741 VSS.n449 87.5005
R3176 VSS.n745 VSS.n739 87.5005
R3177 VSS.n748 VSS.n747 87.5005
R3178 VSS.n752 VSS.n736 87.5005
R3179 VSS.n756 VSS.n754 87.5005
R3180 VSS.n914 VSS.n420 87.5005
R3181 VSS.n907 VSS.n420 87.5005
R3182 VSS.n907 VSS.n432 87.5005
R3183 VSS.n897 VSS.n432 87.5005
R3184 VSS.n897 VSS.n436 87.5005
R3185 VSS.n893 VSS.n436 87.5005
R3186 VSS.n893 VSS.n438 87.5005
R3187 VSS.n884 VSS.n438 87.5005
R3188 VSS.n884 VSS.n443 87.5005
R3189 VSS.n880 VSS.n443 87.5005
R3190 VSS.n880 VSS.n445 87.5005
R3191 VSS.n774 VSS.n445 87.5005
R3192 VSS.n774 VSS.n768 87.5005
R3193 VSS.n768 VSS.n763 87.5005
R3194 VSS.n763 VSS.n762 87.5005
R3195 VSS.n762 VSS.n761 87.5005
R3196 VSS.n761 VSS.n450 87.5005
R3197 VSS.n790 VSS.n450 87.5005
R3198 VSS.n919 VSS.n918 87.5005
R3199 VSS.n923 VSS.n922 87.5005
R3200 VSS.n927 VSS.n926 87.5005
R3201 VSS.n931 VSS.n430 87.5005
R3202 VSS.n74 VSS.n65 87.5005
R3203 VSS.n1464 VSS.n74 87.5005
R3204 VSS.n1464 VSS.n73 87.5005
R3205 VSS.n1459 VSS.n73 87.5005
R3206 VSS.n1459 VSS.n76 87.5005
R3207 VSS.n1450 VSS.n76 87.5005
R3208 VSS.n1450 VSS.n80 87.5005
R3209 VSS.n1446 VSS.n80 87.5005
R3210 VSS.n1446 VSS.n82 87.5005
R3211 VSS.n1440 VSS.n82 87.5005
R3212 VSS.n1440 VSS.n87 87.5005
R3213 VSS.n1436 VSS.n87 87.5005
R3214 VSS.n1436 VSS.n89 87.5005
R3215 VSS.n298 VSS.n89 87.5005
R3216 VSS.n1199 VSS.n298 87.5005
R3217 VSS.n1199 VSS.n295 87.5005
R3218 VSS.n1203 VSS.n295 87.5005
R3219 VSS.n1203 VSS.n294 87.5005
R3220 VSS.n985 VSS.n978 87.5005
R3221 VSS.n987 VSS.n976 87.5005
R3222 VSS.n990 VSS.n976 87.5005
R3223 VSS.n992 VSS.n980 87.5005
R3224 VSS.n995 VSS.n980 87.5005
R3225 VSS.n997 VSS.n982 87.5005
R3226 VSS.n1470 VSS.n69 87.5005
R3227 VSS.n1466 VSS.n69 87.5005
R3228 VSS.n1466 VSS.n71 87.5005
R3229 VSS.n1456 VSS.n71 87.5005
R3230 VSS.n1456 VSS.n77 87.5005
R3231 VSS.n1452 VSS.n77 87.5005
R3232 VSS.n1452 VSS.n79 87.5005
R3233 VSS.n1445 VSS.n79 87.5005
R3234 VSS.n1445 VSS.n83 87.5005
R3235 VSS.n1441 VSS.n83 87.5005
R3236 VSS.n1441 VSS.n85 87.5005
R3237 VSS.n90 VSS.n85 87.5005
R3238 VSS.n1163 VSS.n90 87.5005
R3239 VSS.n1163 VSS.n310 87.5005
R3240 VSS.n310 VSS.n300 87.5005
R3241 VSS.n1157 VSS.n300 87.5005
R3242 VSS.n1157 VSS.n293 87.5005
R3243 VSS.n373 VSS.n293 87.5005
R3244 VSS.n1475 VSS.n1474 87.5005
R3245 VSS.n1479 VSS.n1478 87.5005
R3246 VSS.n1483 VSS.n1482 87.5005
R3247 VSS.n1487 VSS.n1486 87.5005
R3248 VSS.n1536 VSS.t604 82.5402
R3249 VSS.t254 VSS.n36 82.5402
R3250 VSS.n1330 VSS.n186 77.0005
R3251 VSS.n1431 VSS.n1430 72.8296
R3252 VSS.n1434 VSS.n1433 72.8296
R3253 VSS.n891 VSS.n439 72.8296
R3254 VSS.n879 VSS.n446 72.8296
R3255 VSS.n216 VSS.n211 68.2505
R3256 VSS.n1571 VSS.n6 68.2505
R3257 VSS.n1500 VSS.n58 68.2505
R3258 VSS.n790 VSS.n449 68.2505
R3259 VSS.n915 VSS.n914 68.2505
R3260 VSS.n978 VSS.n373 68.2505
R3261 VSS.n1471 VSS.n1470 68.2505
R3262 VSS.t425 VSS.n1457 65.5467
R3263 VSS.n905 VSS.t439 65.5467
R3264 VSS.n782 VSS.t469 65.5467
R3265 VSS.n1295 VSS.n181 65.0005
R3266 VSS.n1515 VSS.t461 61.9053
R3267 VSS.n1556 VSS.t598 61.9053
R3268 VSS.n1457 VSS.t435 61.9053
R3269 VSS.t590 VSS.n905 61.9053
R3270 VSS.t429 VSS.n782 61.9053
R3271 VSS.n1273 VSS.n1272 60.8596
R3272 VSS.n1305 VSS.n199 59.5005
R3273 VSS.n1164 VSS.n305 59.5005
R3274 VSS.n1222 VSS.n280 59.5005
R3275 VSS.n1106 VSS.n340 59.5005
R3276 VSS.n1070 VSS.n356 59.5005
R3277 VSS.n661 VSS.n660 59.5005
R3278 VSS.n692 VSS.n474 59.5005
R3279 VSS.n732 VSS.n273 56.6252
R3280 VSS.n238 VSS.t258 55.2129
R3281 VSS.t387 VSS.n226 55.2129
R3282 VSS.n258 VSS.t173 55.2129
R3283 VSS.n259 VSS.t355 55.2129
R3284 VSS.n261 VSS.t423 55.2129
R3285 VSS.n262 VSS.t243 55.2129
R3286 VSS.n225 VSS.t424 55.2129
R3287 VSS.t483 VSS.n221 55.2129
R3288 VSS.n270 VSS.t450 55.2129
R3289 VSS.n271 VSS.t382 55.2129
R3290 VSS.t383 VSS.n1276 55.2129
R3291 VSS.n1275 VSS.t384 55.2129
R3292 VSS.n1272 VSS.t388 55.2129
R3293 VSS.t389 VSS.n212 55.2129
R3294 VSS.n380 VSS.n281 54.6223
R3295 VSS.n969 VSS.n378 54.6223
R3296 VSS.n941 VSS.n940 54.6223
R3297 VSS.n554 VSS.n502 54.6223
R3298 VSS.n540 VSS.n513 54.6223
R3299 VSS.n256 VSS.n228 52.5005
R3300 VSS.n256 VSS.n227 52.5005
R3301 VSS.n227 VSS.n224 52.5005
R3302 VSS.n264 VSS.n224 52.5005
R3303 VSS.n264 VSS.n222 52.5005
R3304 VSS.n268 VSS.n222 52.5005
R3305 VSS.n268 VSS.n220 52.5005
R3306 VSS.n1277 VSS.n220 52.5005
R3307 VSS.n1277 VSS.n213 52.5005
R3308 VSS.n1281 VSS.n213 52.5005
R3309 VSS.n1281 VSS.n211 52.5005
R3310 VSS.n1301 VSS.n199 52.5005
R3311 VSS.n1301 VSS.n200 52.5005
R3312 VSS.n1297 VSS.n200 52.5005
R3313 VSS.n1297 VSS.n202 52.5005
R3314 VSS.n243 VSS.n202 52.5005
R3315 VSS.n246 VSS.n243 52.5005
R3316 VSS.n249 VSS.n248 52.5005
R3317 VSS.n1305 VSS.n197 52.5005
R3318 VSS.n1309 VSS.n197 52.5005
R3319 VSS.n1309 VSS.n195 52.5005
R3320 VSS.n1313 VSS.n195 52.5005
R3321 VSS.n1313 VSS.n193 52.5005
R3322 VSS.n1317 VSS.n193 52.5005
R3323 VSS.n1317 VSS.n191 52.5005
R3324 VSS.n1321 VSS.n191 52.5005
R3325 VSS.n1321 VSS.n189 52.5005
R3326 VSS.n1325 VSS.n189 52.5005
R3327 VSS.n1325 VSS.n186 52.5005
R3328 VSS.n1330 VSS.n183 52.5005
R3329 VSS.n1334 VSS.n183 52.5005
R3330 VSS.n1334 VSS.n182 52.5005
R3331 VSS.n1290 VSS.n182 52.5005
R3332 VSS.n1286 VSS.n205 52.5005
R3333 VSS.n214 VSS.n207 52.5005
R3334 VSS.n1234 VSS.n1233 52.5005
R3335 VSS.n1235 VSS.n1234 52.5005
R3336 VSS.n1239 VSS.n1230 52.5005
R3337 VSS.n1242 VSS.n1241 52.5005
R3338 VSS.n1246 VSS.n1227 52.5005
R3339 VSS.n1173 VSS.n176 52.5005
R3340 VSS.n1177 VSS.n1176 52.5005
R3341 VSS.n1185 VSS.n1184 52.5005
R3342 VSS.n1189 VSS.n1165 52.5005
R3343 VSS.n1194 VSS.n305 52.5005
R3344 VSS.n1194 VSS.n302 52.5005
R3345 VSS.n1198 VSS.n302 52.5005
R3346 VSS.n1198 VSS.n301 52.5005
R3347 VSS.n369 VSS.n301 52.5005
R3348 VSS.n1063 VSS.n369 52.5005
R3349 VSS.n1063 VSS.n368 52.5005
R3350 VSS.n1058 VSS.n368 52.5005
R3351 VSS.n1058 VSS.n372 52.5005
R3352 VSS.n372 VSS.n283 52.5005
R3353 VSS.n1259 VSS.n1258 52.5005
R3354 VSS.n1263 VSS.n1262 52.5005
R3355 VSS.n1265 VSS.n277 52.5005
R3356 VSS.n1269 VSS.n278 52.5005
R3357 VSS.n1104 VSS.n1103 52.5005
R3358 VSS.n1101 VSS.n342 52.5005
R3359 VSS.n1097 VSS.n1095 52.5005
R3360 VSS.n1120 VSS.n1119 52.5005
R3361 VSS.n1124 VSS.n337 52.5005
R3362 VSS.n1127 VSS.n1126 52.5005
R3363 VSS.n1073 VSS.n1072 52.5005
R3364 VSS.n1077 VSS.n353 52.5005
R3365 VSS.n1080 VSS.n1079 52.5005
R3366 VSS.n1142 VSS.n1141 52.5005
R3367 VSS.n1146 VSS.n323 52.5005
R3368 VSS.n1149 VSS.n1148 52.5005
R3369 VSS.n650 VSS.n649 52.5005
R3370 VSS.n646 VSS.n645 52.5005
R3371 VSS.n642 VSS.n641 52.5005
R3372 VSS.n615 VSS.n459 52.5005
R3373 VSS.n619 VSS.n618 52.5005
R3374 VSS.n623 VSS.n622 52.5005
R3375 VSS.n495 VSS.n481 52.5005
R3376 VSS.n567 VSS.n495 52.5005
R3377 VSS.n567 VSS.n493 52.5005
R3378 VSS.n562 VSS.n493 52.5005
R3379 VSS.n562 VSS.n497 52.5005
R3380 VSS.n553 VSS.n497 52.5005
R3381 VSS.n553 VSS.n504 52.5005
R3382 VSS.n549 VSS.n504 52.5005
R3383 VSS.n549 VSS.n506 52.5005
R3384 VSS.n539 VSS.n506 52.5005
R3385 VSS.n526 VSS.n519 52.5005
R3386 VSS.n529 VSS.n528 52.5005
R3387 VSS.n533 VSS.n532 52.5005
R3388 VSS.n535 VSS.n533 52.5005
R3389 VSS.n573 VSS.n489 52.5005
R3390 VSS.n569 VSS.n489 52.5005
R3391 VSS.n569 VSS.n491 52.5005
R3392 VSS.n559 VSS.n491 52.5005
R3393 VSS.n559 VSS.n499 52.5005
R3394 VSS.n555 VSS.n499 52.5005
R3395 VSS.n555 VSS.n501 52.5005
R3396 VSS.n545 VSS.n501 52.5005
R3397 VSS.n545 VSS.n507 52.5005
R3398 VSS.n541 VSS.n507 52.5005
R3399 VSS.n582 VSS.n581 52.5005
R3400 VSS.n586 VSS.n585 52.5005
R3401 VSS.n590 VSS.n589 52.5005
R3402 VSS.n594 VSS.n482 52.5005
R3403 VSS.n678 VSS.n475 52.5005
R3404 VSS.n682 VSS.n681 52.5005
R3405 VSS.n684 VSS.n604 52.5005
R3406 VSS.n704 VSS.n703 52.5005
R3407 VSS.n708 VSS.n707 52.5005
R3408 VSS.n712 VSS.n711 52.5005
R3409 VSS.n1207 VSS.n290 52.5005
R3410 VSS.n1207 VSS.n287 52.5005
R3411 VSS.n1211 VSS.n287 52.5005
R3412 VSS.n1211 VSS.n286 52.5005
R3413 VSS.n963 VSS.n286 52.5005
R3414 VSS.n964 VSS.n963 52.5005
R3415 VSS.n964 VSS.n381 52.5005
R3416 VSS.n968 VSS.n381 52.5005
R3417 VSS.n968 VSS.n379 52.5005
R3418 VSS.n959 VSS.n379 52.5005
R3419 VSS.n959 VSS.n383 52.5005
R3420 VSS.n390 VSS.n383 52.5005
R3421 VSS.n947 VSS.n390 52.5005
R3422 VSS.n947 VSS.n389 52.5005
R3423 VSS.n942 VSS.n389 52.5005
R3424 VSS.n411 VSS.n409 52.5005
R3425 VSS.n407 VSS.n396 52.5005
R3426 VSS.n403 VSS.n396 52.5005
R3427 VSS.n401 VSS.n400 52.5005
R3428 VSS.n1045 VSS.n292 52.5005
R3429 VSS.n1049 VSS.n292 52.5005
R3430 VSS.n1049 VSS.n284 52.5005
R3431 VSS.n1005 VSS.n284 52.5005
R3432 VSS.n1005 VSS.n975 52.5005
R3433 VSS.n975 VSS.n974 52.5005
R3434 VSS.n974 VSS.n375 52.5005
R3435 VSS.n970 VSS.n375 52.5005
R3436 VSS.n970 VSS.n377 52.5005
R3437 VSS.n384 VSS.n377 52.5005
R3438 VSS.n954 VSS.n384 52.5005
R3439 VSS.n954 VSS.n385 52.5005
R3440 VSS.n949 VSS.n385 52.5005
R3441 VSS.n949 VSS.n387 52.5005
R3442 VSS.n419 VSS.n387 52.5005
R3443 VSS.n1027 VSS.n1026 52.5005
R3444 VSS.n1024 VSS.n1011 52.5005
R3445 VSS.n1020 VSS.n1018 52.5005
R3446 VSS.n1016 VSS.n1013 52.5005
R3447 VSS.n899 VSS.t250 50.9809
R3448 VSS.t28 VSS.n476 50.9809
R3449 VSS.n554 VSS.t101 50.9809
R3450 VSS.n1293 VSS.t11 50.7817
R3451 VSS.n251 VSS.n228 50.7505
R3452 VSS.n1512 VSS.n55 50.7505
R3453 VSS.n1567 VSS.n13 50.7505
R3454 VSS.n1339 VSS.n1338 50.7505
R3455 VSS.n1250 VSS.n1249 50.7505
R3456 VSS.n574 VSS.n573 50.7505
R3457 VSS.n594 VSS.n481 50.7505
R3458 VSS.n419 VSS.n394 50.7505
R3459 VSS.n1045 VSS.n1034 50.7505
R3460 VSS.n788 VSS.n733 50.7505
R3461 VSS.n934 VSS.n422 50.7505
R3462 VSS.n1001 VSS.n294 50.7505
R3463 VSS.n1491 VSS.n65 50.7505
R3464 VSS.t184 VSS.t479 47.3394
R3465 VSS.n86 VSS.t85 47.3394
R3466 VSS.t431 VSS.t180 47.3394
R3467 VSS.n885 VSS.t494 47.3394
R3468 VSS.t588 VSS.t268 47.3394
R3469 VSS.n1274 VSS.n1273 47.0565
R3470 VSS.n1191 VSS.t169 45.5187
R3471 VSS.n1512 VSS.n1497 43.7505
R3472 VSS.n1093 VSS.n344 42.0005
R3473 VSS.n1133 VSS.n331 42.0005
R3474 VSS.n1082 VSS.n349 42.0005
R3475 VSS.n1139 VSS.n326 42.0005
R3476 VSS.n638 VSS.n611 42.0005
R3477 VSS.n728 VSS.n460 42.0005
R3478 VSS.n539 VSS.n514 42.0005
R3479 VSS.n541 VSS.n509 42.0005
R3480 VSS.n688 VSS.n605 42.0005
R3481 VSS.n722 VSS.n721 42.0005
R3482 VSS.n942 VSS.n392 42.0005
R3483 VSS.n1013 VSS.n290 42.0005
R3484 VSS.n1492 VSS.n59 41.8773
R3485 VSS.n789 VSS.n731 41.8773
R3486 VSS.n690 VSS.n599 41.8773
R3487 VSS.t461 VSS.t481 41.2703
R3488 VSS.t481 VSS.t608 41.2703
R3489 VSS.t415 VSS.t364 41.2703
R3490 VSS.t364 VSS.t419 41.2703
R3491 VSS.t419 VSS.t417 41.2703
R3492 VSS.t145 VSS.t149 41.2703
R3493 VSS.t149 VSS.t147 41.2703
R3494 VSS.t147 VSS.t151 41.2703
R3495 VSS.t43 VSS.t51 41.2703
R3496 VSS.t51 VSS.t53 41.2703
R3497 VSS.t53 VSS.t47 41.2703
R3498 VSS.t47 VSS.t55 41.2703
R3499 VSS.t55 VSS.t32 41.2703
R3500 VSS.t58 VSS.t32 41.2703
R3501 VSS.t58 VSS.t45 41.2703
R3502 VSS.t64 VSS.t49 41.2703
R3503 VSS.t66 VSS.t64 41.2703
R3504 VSS.t62 VSS.t66 41.2703
R3505 VSS.t68 VSS.t70 41.2703
R3506 VSS.t70 VSS.t60 41.2703
R3507 VSS.t60 VSS.t72 41.2703
R3508 VSS.t489 VSS.t594 41.2703
R3509 VSS.t594 VSS.t602 41.2703
R3510 VSS.t596 VSS.t600 41.2703
R3511 VSS.t600 VSS.t592 41.2703
R3512 VSS.t199 VSS.t214 41.2703
R3513 VSS.t214 VSS.t0 41.2703
R3514 VSS.t0 VSS.t103 41.2703
R3515 VSS.t102 VSS.t218 41.2703
R3516 VSS.t218 VSS.t220 41.2703
R3517 VSS.t220 VSS.t222 41.2703
R3518 VSS.t203 VSS.t201 41.2703
R3519 VSS.t203 VSS.t77 41.2703
R3520 VSS.t35 VSS.t77 41.2703
R3521 VSS.t33 VSS.t35 41.2703
R3522 VSS.t31 VSS.t33 41.2703
R3523 VSS.t209 VSS.t31 41.2703
R3524 VSS.t211 VSS.t209 41.2703
R3525 VSS.t136 VSS.t138 41.2703
R3526 VSS.t138 VSS.t140 41.2703
R3527 VSS.t140 VSS.t142 41.2703
R3528 VSS.t115 VSS.t113 41.2703
R3529 VSS.t117 VSS.t115 41.2703
R3530 VSS.t119 VSS.t117 41.2703
R3531 VSS.t403 VSS.t487 41.2703
R3532 VSS.t598 VSS.t403 41.2703
R3533 VSS.n306 VSS.n299 39.9818
R3534 VSS.n208 VSS.n177 39.1571
R3535 VSS.n719 VSS.n451 36.4151
R3536 VSS.n1249 VSS.n1248 35.0005
R3537 VSS.n283 VSS.n280 35.0005
R3538 VSS.n1131 VSS.n316 35.0005
R3539 VSS.n1040 VSS.n316 35.0005
R3540 VSS.n1040 VSS.n346 35.0005
R3541 VSS.n1089 VSS.n346 35.0005
R3542 VSS.n1089 VSS.n344 35.0005
R3543 VSS.n1133 VSS.n314 35.0005
R3544 VSS.n1038 VSS.n314 35.0005
R3545 VSS.n1038 VSS.n367 35.0005
R3546 VSS.n367 VSS.n348 35.0005
R3547 VSS.n348 VSS.n340 35.0005
R3548 VSS.n1155 VSS.n318 35.0005
R3549 VSS.n1155 VSS.n317 35.0005
R3550 VSS.n350 VSS.n317 35.0005
R3551 VSS.n1087 VSS.n350 35.0005
R3552 VSS.n1087 VSS.n349 35.0005
R3553 VSS.n326 VSS.n313 35.0005
R3554 VSS.n366 VSS.n313 35.0005
R3555 VSS.n1065 VSS.n366 35.0005
R3556 VSS.n1065 VSS.n347 35.0005
R3557 VSS.n356 VSS.n347 35.0005
R3558 VSS.n627 VSS.n468 35.0005
R3559 VSS.n669 VSS.n468 35.0005
R3560 VSS.n669 VSS.n612 35.0005
R3561 VSS.n673 VSS.n612 35.0005
R3562 VSS.n673 VSS.n611 35.0005
R3563 VSS.n467 VSS.n460 35.0005
R3564 VSS.n667 VSS.n467 35.0005
R3565 VSS.n667 VSS.n637 35.0005
R3566 VSS.n637 VSS.n610 35.0005
R3567 VSS.n661 VSS.n610 35.0005
R3568 VSS.n718 VSS.n470 35.0005
R3569 VSS.n718 VSS.n469 35.0005
R3570 VSS.n607 VSS.n469 35.0005
R3571 VSS.n675 VSS.n607 35.0005
R3572 VSS.n675 VSS.n605 35.0005
R3573 VSS.n722 VSS.n720 35.0005
R3574 VSS.n720 VSS.n465 35.0005
R3575 VSS.n635 VSS.n465 35.0005
R3576 VSS.n635 VSS.n609 35.0005
R3577 VSS.n609 VSS.n474 35.0005
R3578 VSS.n783 VSS.n273 34.4123
R3579 VSS.n1435 VSS.t171 32.7736
R3580 VSS.n892 VSS.t248 32.7736
R3581 VSS.n1433 VSS.n1432 29.6637
R3582 VSS.n878 VSS.n439 29.6637
R3583 VSS.n1535 VSS.n1534 29.6637
R3584 VSS.n608 VSS.n599 29.3142
R3585 VSS.n488 VSS.n1 28.4449
R3586 VSS.n1432 VSS.n1431 28.4005
R3587 VSS.n879 VSS.n878 28.4005
R3588 VSS.n1534 VSS.n1533 28.4005
R3589 VSS.n380 VSS.n35 27.3114
R3590 VSS.n969 VSS.n35 27.3114
R3591 VSS.n934 VSS.n425 26.2505
R3592 VSS.n1491 VSS.n66 26.2505
R3593 VSS.t258 VSS.t40 25.097
R3594 VSS.t40 VSS.t387 25.097
R3595 VSS.t506 VSS.t173 25.097
R3596 VSS.t506 VSS.t355 25.097
R3597 VSS.t423 VSS.t124 25.097
R3598 VSS.t124 VSS.t243 25.097
R3599 VSS.t424 VSS.t422 25.097
R3600 VSS.t422 VSS.t483 25.097
R3601 VSS.t450 VSS.t30 25.097
R3602 VSS.t30 VSS.t382 25.097
R3603 VSS.t345 VSS.t383 25.097
R3604 VSS.t345 VSS.t384 25.097
R3605 VSS.t388 VSS.t158 25.097
R3606 VSS.t158 VSS.t389 25.097
R3607 VSS.n131 VSS.n130 24.6095
R3608 VSS.n133 VSS.n132 24.6095
R3609 VSS.n1131 VSS.n333 24.5005
R3610 VSS.n1151 VSS.n318 24.5005
R3611 VSS.n627 VSS.n626 24.5005
R3612 VSS.n714 VSS.n470 24.5005
R3613 VSS.n1408 VSS.t185 23.9124
R3614 VSS.n865 VSS.t589 23.9124
R3615 VSS.n1377 VSS.t434 23.8177
R3616 VSS.n836 VSS.t432 23.8177
R3617 VSS.n1394 VSS.n1393 23.8024
R3618 VSS.n813 VSS.n812 23.8024
R3619 VSS.n1363 VSS.n1362 23.7551
R3620 VSS.n822 VSS.n821 23.7551
R3621 VSS.n1132 VSS.n321 23.67
R3622 VSS.t620 VSS.n378 23.67
R3623 VSS.n941 VSS.n393 23.67
R3624 VSS.n730 VSS.n451 23.67
R3625 VSS.n595 VSS.n476 23.67
R3626 VSS.n1336 VSS.n177 23.4945
R3627 VSS.t227 VSS.t505 21.8492
R3628 VSS.t105 VSS.t233 21.8492
R3629 VSS.n1008 VSS.n172 21.3764
R3630 VSS.n1429 VSS.n68 21.0437
R3631 VSS.n877 VSS.n792 21.0437
R3632 VSS.n1513 VSS.n1493 20.6354
R3633 VSS.n43 VSS.t62 20.6354
R3634 VSS.n43 VSS.t68 20.6354
R3635 VSS.n1535 VSS.t606 20.6354
R3636 VSS.t604 VSS.n1535 20.6354
R3637 VSS.n1533 VSS.t254 20.6354
R3638 VSS.n1533 VSS.t252 20.6354
R3639 VSS.t103 VSS.n31 20.6354
R3640 VSS.n31 VSS.t102 20.6354
R3641 VSS.n1569 VSS.n8 20.6354
R3642 VSS.n725 VSS.n724 20.0894
R3643 VSS.n1220 VSS.t508 20.0285
R3644 VSS.n253 VSS.n236 20.0247
R3645 VSS.n1342 VSS.n1341 19.8527
R3646 VSS.n1335 VSS.n181 19.5788
R3647 VSS.t454 VSS.n1193 19.219
R3648 VSS.n1137 VSS.n1136 19.1783
R3649 VSS.n1136 VSS.n1135 18.8227
R3650 VSS.n1367 VSS.n1366 18.5679
R3651 VSS.n826 VSS.n825 18.5679
R3652 VSS.n94 VSS.n93 18.5483
R3653 VSS.n171 VSS.n170 18.5483
R3654 VSS.n797 VSS.n794 18.2754
R3655 VSS.n835 VSS.n834 18.2754
R3656 VSS.n1376 VSS.n1375 18.2754
R3657 VSS.n1415 VSS.n1409 18.2754
R3658 VSS.t184 VSS.n1327 18.2078
R3659 VSS.t433 VSS.n1192 18.2078
R3660 VSS.n899 VSS.t431 18.2078
R3661 VSS.n767 VSS.t588 18.2078
R3662 VSS.t29 VSS.n492 18.1864
R3663 VSS.t100 VSS.n498 18.1864
R3664 VSS.n1373 VSS.n1368 18.157
R3665 VSS.n1417 VSS.n1416 18.157
R3666 VSS.n1426 VSS.n1425 18.157
R3667 VSS.n874 VSS.n873 18.157
R3668 VSS.n803 VSS.n802 18.157
R3669 VSS.n832 VSS.n827 18.157
R3670 VSS.n726 VSS.n725 18.0005
R3671 VSS.n957 VSS.t621 16.5691
R3672 VSS.t509 VSS.n388 16.5691
R3673 VSS.t12 VSS.n1212 16.3871
R3674 VSS.n955 VSS.t22 16.3871
R3675 VSS.n912 VSS.t26 16.3871
R3676 VSS.n321 VSS.n299 16.3123
R3677 VSS.n1577 VSS.n1576 15.7055
R3678 VSS.n146 VSS.n135 15.2627
R3679 VSS.n104 VSS.n103 15.2222
R3680 VSS.n162 VSS.n161 15.2222
R3681 VSS.n230 VSS.t112 15.202
R3682 VSS.n1273 VSS.n1271 15.1168
R3683 VSS.t1 VSS.t282 14.5663
R3684 VSS.t627 VSS.t175 14.5663
R3685 VSS.t176 VSS.t348 14.5663
R3686 VSS.t130 VSS.t261 14.5663
R3687 VSS.n939 VSS.t510 14.5663
R3688 VSS.t366 VSS.t412 14.5663
R3689 VSS.n568 VSS.t504 14.5663
R3690 VSS.n561 VSS.t106 14.5663
R3691 VSS.n540 VSS.n510 14.5663
R3692 VSS.n1343 VSS.n0 14.4602
R3693 VSS.n230 VSS.t104 14.302
R3694 VSS.n231 VSS.t107 14.302
R3695 VSS.n232 VSS.t535 14.302
R3696 VSS.n233 VSS.t380 14.302
R3697 VSS.n234 VSS.t42 14.302
R3698 VSS.n235 VSS.t349 14.302
R3699 VSS.n99 VSS.n95 13.793
R3700 VSS.n167 VSS.n163 13.793
R3701 VSS.n416 VSS.n415 13.5139
R3702 VSS.n1032 VSS.n1031 13.5139
R3703 VSS.n1574 VSS.n1573 13.5005
R3704 VSS.n108 VSS.n105 13.2657
R3705 VSS.n151 VSS.n148 13.2657
R3706 VSS.n579 VSS.n578 13.022
R3707 VSS.n487 VSS.n486 13.022
R3708 VSS.n114 VSS.n106 12.9149
R3709 VSS.n157 VSS.n149 12.9149
R3710 VSS.n1055 VSS.t127 12.5635
R3711 VSS.t346 VSS.n466 12.5635
R3712 VSS.n631 VSS.t385 12.5635
R3713 VSS.n546 VSS.t392 12.5635
R3714 VSS.n547 VSS.t451 12.5635
R3715 VSS.n511 VSS.t108 12.5635
R3716 VSS.n512 VSS.t121 12.5635
R3717 VSS.n138 VSS.n137 12.4151
R3718 VSS.n524 VSS.n523 12.392
R3719 VSS.n1387 VSS.n1386 11.7005
R3720 VSS.n1396 VSS.n1395 11.7005
R3721 VSS.n1407 VSS.n1406 11.7005
R3722 VSS.n864 VSS.n863 11.7005
R3723 VSS.n860 VSS.n847 11.7005
R3724 VSS.n820 VSS.n819 11.7005
R3725 VSS.n1218 VSS.t154 11.6532
R3726 VSS.n1051 VSS.n1050 11.1069
R3727 VSS.n719 VSS.n466 11.1069
R3728 VSS.n122 VSS.n116 11.0126
R3729 VSS.n1431 VSS.t78 10.9249
R3730 VSS.n1433 VSS.t8 10.9249
R3731 VSS.t128 VSS.t9 10.9249
R3732 VSS.t174 VSS.t87 10.9249
R3733 VSS.t177 VSS.t502 10.9249
R3734 VSS.t414 VSS.t129 10.9249
R3735 VSS.t405 VSS.n439 10.9249
R3736 VSS.t501 VSS.n879 10.9249
R3737 VSS.n100 VSS.n99 10.7222
R3738 VSS.n168 VSS.n167 10.7222
R3739 VSS.n1344 VSS.n1343 10.2826
R3740 VSS.n357 VSS.n327 10.2705
R3741 VSS.n363 VSS.n362 10.2705
R3742 VSS.n1115 VSS.n1114 10.2705
R3743 VSS.n1109 VSS.n1108 10.2705
R3744 VSS.n652 VSS.n461 10.2705
R3745 VSS.n658 VSS.n657 10.2705
R3746 VSS.n701 VSS.n700 10.2705
R3747 VSS.n695 VSS.n694 10.2705
R3748 VSS.n120 VSS.n119 9.98011
R3749 VSS.n1042 VSS.t88 9.28621
R3750 VSS.t287 VSS.n630 9.28621
R3751 VSS.t292 VSS.n631 9.28621
R3752 VSS.t612 VSS.n547 9.28621
R3753 VSS.n511 VSS.t616 9.28621
R3754 VSS.t131 VSS.n1054 9.10414
R3755 VSS.n1004 VSS.t122 9.10414
R3756 VSS.n958 VSS.t348 9.10414
R3757 VSS.n948 VSS.t261 9.10414
R3758 VSS.n940 VSS.n939 9.10414
R3759 VSS.n307 VSS.t390 8.92207
R3760 VSS.n115 VSS.n114 8.76572
R3761 VSS.n158 VSS.n157 8.76572
R3762 VSS.n1193 VSS.t433 8.29465
R3763 VSS.n120 VSS.n118 7.51148
R3764 VSS.n1043 VSS.n312 7.46549
R3765 VSS.t167 VSS.n299 7.32154
R3766 VSS.n492 VSS.t516 7.29487
R3767 VSS.n498 VSS.t133 7.29487
R3768 VSS.n1465 VSS.t362 7.28341
R3769 VSS.t360 VSS.t362 7.28341
R3770 VSS.t437 VSS.t360 7.28341
R3771 VSS.t435 VSS.t437 7.28341
R3772 VSS.t452 VSS.t425 7.28341
R3773 VSS.t399 VSS.t452 7.28341
R3774 VSS.t401 VSS.t399 7.28341
R3775 VSS.t259 VSS.t256 7.28341
R3776 VSS.t444 VSS.t259 7.28341
R3777 VSS.t479 VSS.t444 7.28341
R3778 VSS.n1327 VSS.t305 7.28341
R3779 VSS.t305 VSS.t307 7.28341
R3780 VSS.t307 VSS.t301 7.28341
R3781 VSS.t301 VSS.t309 7.28341
R3782 VSS.t309 VSS.t311 7.28341
R3783 VSS.t311 VSS.t303 7.28341
R3784 VSS.t303 VSS.t299 7.28341
R3785 VSS.t299 VSS.t313 7.28341
R3786 VSS.t313 VSS.t315 7.28341
R3787 VSS.t315 VSS.t317 7.28341
R3788 VSS.t317 VSS.t319 7.28341
R3789 VSS.t319 VSS.t325 7.28341
R3790 VSS.t79 VSS.t78 7.28341
R3791 VSS.t79 VSS.t80 7.28341
R3792 VSS.t81 VSS.t80 7.28341
R3793 VSS.t82 VSS.t81 7.28341
R3794 VSS.t83 VSS.t82 7.28341
R3795 VSS.t84 VSS.t83 7.28341
R3796 VSS.t85 VSS.t84 7.28341
R3797 VSS.t276 VSS.t274 7.28341
R3798 VSS.t278 VSS.t276 7.28341
R3799 VSS.t280 VSS.t278 7.28341
R3800 VSS.t282 VSS.t280 7.28341
R3801 VSS.t2 VSS.t1 7.28341
R3802 VSS.t3 VSS.t2 7.28341
R3803 VSS.t4 VSS.t3 7.28341
R3804 VSS.t5 VSS.t4 7.28341
R3805 VSS.t6 VSS.t5 7.28341
R3806 VSS.t7 VSS.t6 7.28341
R3807 VSS.t7 VSS.t8 7.28341
R3808 VSS.t485 VSS.t486 7.28341
R3809 VSS.t484 VSS.t485 7.28341
R3810 VSS.t226 VSS.t484 7.28341
R3811 VSS.t225 VSS.t226 7.28341
R3812 VSS.t224 VSS.t225 7.28341
R3813 VSS.t76 VSS.t224 7.28341
R3814 VSS.t75 VSS.t76 7.28341
R3815 VSS.t74 VSS.t75 7.28341
R3816 VSS.t157 VSS.t74 7.28341
R3817 VSS.t156 VSS.t157 7.28341
R3818 VSS.t155 VSS.t156 7.28341
R3819 VSS.t169 VSS.t171 7.28341
R3820 VSS.t584 VSS.t454 7.28341
R3821 VSS.t584 VSS.t586 7.28341
R3822 VSS.t477 VSS.t586 7.28341
R3823 VSS.t473 VSS.t475 7.28341
R3824 VSS.t191 VSS.t473 7.28341
R3825 VSS.t390 VSS.t191 7.28341
R3826 VSS.t182 VSS.t197 7.28341
R3827 VSS.t195 VSS.t193 7.28341
R3828 VSS.t88 VSS.t90 7.28341
R3829 VSS.t90 VSS.t92 7.28341
R3830 VSS.t18 VSS.t12 7.28341
R3831 VSS.t122 VSS.t14 7.28341
R3832 VSS.t621 VSS.t620 7.28341
R3833 VSS.t502 VSS.t503 7.28341
R3834 VSS.t16 VSS.t24 7.28341
R3835 VSS.t26 VSS.t16 7.28341
R3836 VSS.t510 VSS.t509 7.28341
R3837 VSS.n906 VSS.t239 7.28341
R3838 VSS.t239 VSS.t237 7.28341
R3839 VSS.t237 VSS.t235 7.28341
R3840 VSS.t235 VSS.t590 7.28341
R3841 VSS.t465 VSS.t439 7.28341
R3842 VSS.t358 VSS.t465 7.28341
R3843 VSS.t178 VSS.t358 7.28341
R3844 VSS.t393 VSS.t397 7.28341
R3845 VSS.t471 VSS.t393 7.28341
R3846 VSS.t180 VSS.t471 7.28341
R3847 VSS.t248 VSS.t250 7.28341
R3848 VSS.t456 VSS.t162 7.28341
R3849 VSS.t162 VSS.t161 7.28341
R3850 VSS.t161 VSS.t160 7.28341
R3851 VSS.t160 VSS.t159 7.28341
R3852 VSS.t159 VSS.t166 7.28341
R3853 VSS.t166 VSS.t165 7.28341
R3854 VSS.t165 VSS.t164 7.28341
R3855 VSS.t164 VSS.t163 7.28341
R3856 VSS.t163 VSS.t443 7.28341
R3857 VSS.t443 VSS.t442 7.28341
R3858 VSS.t442 VSS.t441 7.28341
R3859 VSS.t406 VSS.t405 7.28341
R3860 VSS.t407 VSS.t406 7.28341
R3861 VSS.t408 VSS.t407 7.28341
R3862 VSS.t409 VSS.t408 7.28341
R3863 VSS.t410 VSS.t409 7.28341
R3864 VSS.t411 VSS.t410 7.28341
R3865 VSS.t412 VSS.t411 7.28341
R3866 VSS.t368 VSS.t366 7.28341
R3867 VSS.t370 VSS.t368 7.28341
R3868 VSS.t374 VSS.t370 7.28341
R3869 VSS.t372 VSS.t374 7.28341
R3870 VSS.t495 VSS.t494 7.28341
R3871 VSS.t496 VSS.t495 7.28341
R3872 VSS.t497 VSS.t496 7.28341
R3873 VSS.t498 VSS.t497 7.28341
R3874 VSS.t499 VSS.t498 7.28341
R3875 VSS.t500 VSS.t499 7.28341
R3876 VSS.t500 VSS.t501 7.28341
R3877 VSS.t558 VSS.t562 7.28341
R3878 VSS.t564 VSS.t558 7.28341
R3879 VSS.t566 VSS.t564 7.28341
R3880 VSS.t459 VSS.t566 7.28341
R3881 VSS.t457 VSS.t459 7.28341
R3882 VSS.t570 VSS.t457 7.28341
R3883 VSS.t574 VSS.t570 7.28341
R3884 VSS.t572 VSS.t574 7.28341
R3885 VSS.t576 VSS.t572 7.28341
R3886 VSS.t578 VSS.t576 7.28341
R3887 VSS.t580 VSS.t578 7.28341
R3888 VSS.n767 VSS.t580 7.28341
R3889 VSS.t268 VSS.t266 7.28341
R3890 VSS.t266 VSS.t356 7.28341
R3891 VSS.t356 VSS.t463 7.28341
R3892 VSS.t264 VSS.t262 7.28341
R3893 VSS.t467 VSS.t264 7.28341
R3894 VSS.t469 VSS.t467 7.28341
R3895 VSS.t427 VSS.t429 7.28341
R3896 VSS.t448 VSS.t427 7.28341
R3897 VSS.t446 VSS.t448 7.28341
R3898 VSS.n783 VSS.t446 7.28341
R3899 VSS.t285 VSS.t287 7.28341
R3900 VSS.t289 VSS.t285 7.28341
R3901 VSS.t505 VSS.t504 7.28341
R3902 VSS.t229 VSS.t227 7.28341
R3903 VSS.t233 VSS.t231 7.28341
R3904 VSS.t106 VSS.t105 7.28341
R3905 VSS.t610 VSS.t612 7.28341
R3906 VSS.t616 VSS.t614 7.28341
R3907 VSS.n236 VSS.n0 7.16497
R3908 VSS.n1044 VSS.n1043 7.10134
R3909 VSS.n1042 VSS.n1041 7.10134
R3910 VSS.t123 VSS.n291 7.10134
R3911 VSS.n1054 VSS.n1053 7.10134
R3912 VSS.n1215 VSS.n282 7.10134
R3913 VSS.n958 VSS.n957 7.10134
R3914 VSS.n948 VSS.n388 7.10134
R3915 VSS.n668 VSS.n630 7.10134
R3916 VSS.n674 VSS.n608 7.10134
R3917 VSS.n690 VSS.n596 7.10134
R3918 VSS.n1534 VSS.n3 6.8599
R3919 VSS.n1168 VSS.t531 6.57557
R3920 VSS.n1132 VSS.n332 6.55512
R3921 VSS.n1156 VSS.n315 6.55512
R3922 VSS.n1217 VSS.t627 6.55512
R3923 VSS.n361 VSS.n358 6.5388
R3924 VSS.n360 VSS.n359 6.5388
R3925 VSS.n1111 VSS.n1110 6.5388
R3926 VSS.n1113 VSS.n1112 6.5388
R3927 VSS.n656 VSS.n653 6.5388
R3928 VSS.n655 VSS.n654 6.5388
R3929 VSS.n697 VSS.n696 6.5388
R3930 VSS.n699 VSS.n698 6.5388
R3931 VSS.n1181 VSS.n1179 6.49615
R3932 VSS.n1255 VSS.t522 6.45713
R3933 VSS.n129 VSS.n128 6.41789
R3934 VSS.n147 VSS.n146 6.41789
R3935 VSS.n138 VSS.n134 6.41789
R3936 VSS.n1254 VSS.n1253 6.41078
R3937 VSS.n415 VSS.n413 6.38826
R3938 VSS.n1031 VSS.n1030 6.38826
R3939 VSS.n523 VSS.n521 6.3881
R3940 VSS.n523 VSS.n522 6.38518
R3941 VSS.n415 VSS.n414 6.38502
R3942 VSS.n1031 VSS.n1029 6.38502
R3943 VSS.n1181 VSS.n1180 6.31615
R3944 VSS.n1168 VSS.n1167 6.29483
R3945 VSS.n1254 VSS.n1252 6.29483
R3946 VSS.n1170 VSS.n1169 6.29333
R3947 VSS.n1182 VSS.n1181 6.278
R3948 VSS.n1344 VSS.n171 6.1385
R3949 VSS.n1575 VSS.n1574 5.8145
R3950 VSS.n725 VSS.n1 5.81161
R3951 VSS.n1386 VSS.t275 5.78141
R3952 VSS.n819 VSS.t373 5.78141
R3953 VSS.n137 VSS.t603 5.7796
R3954 VSS.n578 VSS.n577 5.73984
R3955 VSS.n486 VSS.n485 5.73984
R3956 VSS.n578 VSS.n576 5.73692
R3957 VSS.n486 VSS.n484 5.73692
R3958 VSS.n1385 VSS.n1383 5.66497
R3959 VSS.n1350 VSS.n1348 5.66497
R3960 VSS.n1401 VSS.n1399 5.66497
R3961 VSS.n807 VSS.n805 5.66497
R3962 VSS.n850 VSS.n848 5.66497
R3963 VSS.n818 VSS.n816 5.66497
R3964 VSS.n1171 VSS.n1170 5.6555
R3965 VSS.n1213 VSS.t18 5.64476
R3966 VSS.t87 VSS.n1214 5.64476
R3967 VSS.n1216 VSS.t174 5.64476
R3968 VSS.n956 VSS.t177 5.64476
R3969 VSS.t129 VSS.n911 5.64476
R3970 VSS.n93 VSS.t599 5.63749
R3971 VSS.n170 VSS.t609 5.63749
R3972 VSS.n1256 VSS.n1255 5.5955
R3973 VSS.n118 VSS.t593 5.59012
R3974 VSS.n1366 VSS.n1364 5.57485
R3975 VSS.n1371 VSS.n1369 5.57485
R3976 VSS.n1412 VSS.n1410 5.57485
R3977 VSS.n1425 VSS.n1423 5.57485
R3978 VSS.n873 VSS.n872 5.57485
R3979 VSS.n800 VSS.n798 5.57485
R3980 VSS.n830 VSS.n828 5.57485
R3981 VSS.n825 VSS.n824 5.57485
R3982 VSS.n111 VSS.n109 5.57485
R3983 VSS.n118 VSS.n117 5.57485
R3984 VSS.n125 VSS.n123 5.57485
R3985 VSS.n103 VSS.n102 5.57485
R3986 VSS.n98 VSS.n97 5.57485
R3987 VSS.n154 VSS.n152 5.57485
R3988 VSS.n144 VSS.n142 5.57485
R3989 VSS.n161 VSS.n160 5.57485
R3990 VSS.n166 VSS.n165 5.57485
R3991 VSS.n93 VSS.n92 5.52748
R3992 VSS.n170 VSS.n169 5.52748
R3993 VSS.n1385 VSS.n1384 5.4755
R3994 VSS.n1350 VSS.n1349 5.4755
R3995 VSS.n1352 VSS.n1351 5.4755
R3996 VSS.n1354 VSS.n1353 5.4755
R3997 VSS.n1356 VSS.n1355 5.4755
R3998 VSS.n1358 VSS.n1357 5.4755
R3999 VSS.n1396 VSS.n1359 5.4755
R4000 VSS.n1398 VSS.n1397 5.4755
R4001 VSS.n1405 VSS.n1404 5.4755
R4002 VSS.n1403 VSS.n1402 5.4755
R4003 VSS.n1401 VSS.n1400 5.4755
R4004 VSS.n807 VSS.n806 5.4755
R4005 VSS.n809 VSS.n808 5.4755
R4006 VSS.n811 VSS.n810 5.4755
R4007 VSS.n862 VSS.n861 5.4755
R4008 VSS.n860 VSS.n859 5.4755
R4009 VSS.n858 VSS.n857 5.4755
R4010 VSS.n856 VSS.n855 5.4755
R4011 VSS.n854 VSS.n853 5.4755
R4012 VSS.n852 VSS.n851 5.4755
R4013 VSS.n850 VSS.n849 5.4755
R4014 VSS.n818 VSS.n817 5.4755
R4015 VSS.t323 VSS.t168 5.46268
R4016 VSS.t331 VSS.t190 5.46268
R4017 VSS.t333 VSS.t189 5.46268
R4018 VSS.t329 VSS.t188 5.46268
R4019 VSS.t335 VSS.t39 5.46268
R4020 VSS.t337 VSS.t38 5.46268
R4021 VSS.t321 VSS.t37 5.46268
R4022 VSS.t339 VSS.t111 5.46268
R4023 VSS.t341 VSS.t110 5.46268
R4024 VSS.t297 VSS.t109 5.46268
R4025 VSS.t343 VSS.t623 5.46268
R4026 VSS.n1430 VSS.t622 5.46268
R4027 VSS.t486 VSS.n1434 5.46268
R4028 VSS.n1435 VSS.t155 5.46268
R4029 VSS.n1192 VSS.n1191 5.46268
R4030 VSS.t378 VSS.n1044 5.46268
R4031 VSS.n1041 VSS.t379 5.46268
R4032 VSS.n1064 VSS.t92 5.46268
R4033 VSS.t125 VSS.t123 5.46268
R4034 VSS.t14 VSS.n1003 5.46268
R4035 VSS.n1004 VSS.t86 5.46268
R4036 VSS.t503 VSS.n955 5.46268
R4037 VSS.n933 VSS.t22 5.46268
R4038 VSS.t413 VSS.n912 5.46268
R4039 VSS.n892 VSS.t456 5.46268
R4040 VSS.t441 VSS.n891 5.46268
R4041 VSS.t247 VSS.n446 5.46268
R4042 VSS.t246 VSS.t542 5.46268
R4043 VSS.t245 VSS.t544 5.46268
R4044 VSS.t244 VSS.t540 5.46268
R4045 VSS.t354 VSS.t546 5.46268
R4046 VSS.t353 VSS.t548 5.46268
R4047 VSS.t352 VSS.t538 5.46268
R4048 VSS.t351 VSS.t536 5.46268
R4049 VSS.t273 VSS.t550 5.46268
R4050 VSS.t272 VSS.t552 5.46268
R4051 VSS.t271 VSS.t554 5.46268
R4052 VSS.t270 VSS.t556 5.46268
R4053 VSS.n668 VSS.t347 5.46268
R4054 VSS.n636 VSS.t289 5.46268
R4055 VSS.n674 VSS.t386 5.46268
R4056 VSS.n1366 VSS.n1365 5.38537
R4057 VSS.n1371 VSS.n1370 5.38537
R4058 VSS.n1373 VSS.n1372 5.38537
R4059 VSS.n1375 VSS.n1374 5.38537
R4060 VSS.n1412 VSS.n1411 5.38537
R4061 VSS.n1416 VSS.n1413 5.38537
R4062 VSS.n1415 VSS.n1414 5.38537
R4063 VSS.n1425 VSS.n1424 5.38537
R4064 VSS.n873 VSS.n871 5.38537
R4065 VSS.n797 VSS.n796 5.38537
R4066 VSS.n802 VSS.n801 5.38537
R4067 VSS.n800 VSS.n799 5.38537
R4068 VSS.n834 VSS.n833 5.38537
R4069 VSS.n832 VSS.n831 5.38537
R4070 VSS.n830 VSS.n829 5.38537
R4071 VSS.n825 VSS.n823 5.38537
R4072 VSS.n108 VSS.n107 5.38537
R4073 VSS.n113 VSS.n112 5.38537
R4074 VSS.n111 VSS.n110 5.38537
R4075 VSS.n122 VSS.n121 5.38537
R4076 VSS.n127 VSS.n126 5.38537
R4077 VSS.n125 VSS.n124 5.38537
R4078 VSS.n103 VSS.n101 5.38537
R4079 VSS.n98 VSS.n96 5.38537
R4080 VSS.n151 VSS.n150 5.38537
R4081 VSS.n156 VSS.n155 5.38537
R4082 VSS.n154 VSS.n153 5.38537
R4083 VSS.n140 VSS.n139 5.38537
R4084 VSS.n137 VSS.n136 5.38537
R4085 VSS.n145 VSS.n141 5.38537
R4086 VSS.n144 VSS.n143 5.38537
R4087 VSS.n161 VSS.n159 5.38537
R4088 VSS.n166 VSS.n164 5.38537
R4089 VSS.n128 VSS.n120 5.28311
R4090 VSS.n252 VSS.n251 5.2005
R4091 VSS.n249 VSS.n237 5.2005
R4092 VSS.n248 VSS.n241 5.2005
R4093 VSS.n246 VSS.n245 5.2005
R4094 VSS.n243 VSS.n242 5.2005
R4095 VSS.n244 VSS.n243 5.2005
R4096 VSS.n203 VSS.n202 5.2005
R4097 VSS.n202 VSS.n201 5.2005
R4098 VSS.n1297 VSS.n1296 5.2005
R4099 VSS.n1298 VSS.n1297 5.2005
R4100 VSS.n1295 VSS.n200 5.2005
R4101 VSS.n1299 VSS.n200 5.2005
R4102 VSS.n1302 VSS.n1301 5.2005
R4103 VSS.n1301 VSS.n1300 5.2005
R4104 VSS.n1303 VSS.n199 5.2005
R4105 VSS.n199 VSS.n198 5.2005
R4106 VSS.n1328 VSS.n186 5.2005
R4107 VSS.n186 VSS.n185 5.2005
R4108 VSS.n1326 VSS.n1325 5.2005
R4109 VSS.n1325 VSS.n1324 5.2005
R4110 VSS.n189 VSS.n188 5.2005
R4111 VSS.n1323 VSS.n189 5.2005
R4112 VSS.n1321 VSS.n1320 5.2005
R4113 VSS.n1322 VSS.n1321 5.2005
R4114 VSS.n1319 VSS.n191 5.2005
R4115 VSS.n191 VSS.n190 5.2005
R4116 VSS.n1318 VSS.n1317 5.2005
R4117 VSS.n1317 VSS.n1316 5.2005
R4118 VSS.n193 VSS.n192 5.2005
R4119 VSS.n1315 VSS.n193 5.2005
R4120 VSS.n1313 VSS.n1312 5.2005
R4121 VSS.n1314 VSS.n1313 5.2005
R4122 VSS.n1311 VSS.n195 5.2005
R4123 VSS.n195 VSS.n194 5.2005
R4124 VSS.n1310 VSS.n1309 5.2005
R4125 VSS.n1309 VSS.n1308 5.2005
R4126 VSS.n197 VSS.n196 5.2005
R4127 VSS.n1307 VSS.n197 5.2005
R4128 VSS.n1305 VSS.n1304 5.2005
R4129 VSS.n1306 VSS.n1305 5.2005
R4130 VSS.n217 VSS.n216 5.2005
R4131 VSS.n215 VSS.n214 5.2005
R4132 VSS.n207 VSS.n206 5.2005
R4133 VSS.n1287 VSS.n1286 5.2005
R4134 VSS.n1288 VSS.n205 5.2005
R4135 VSS.n1290 VSS.n1289 5.2005
R4136 VSS.n182 VSS.n177 5.2005
R4137 VSS.n184 VSS.n182 5.2005
R4138 VSS.n1335 VSS.n1334 5.2005
R4139 VSS.n1334 VSS.n1333 5.2005
R4140 VSS.n187 VSS.n183 5.2005
R4141 VSS.n1332 VSS.n183 5.2005
R4142 VSS.n1330 VSS.n1329 5.2005
R4143 VSS.n1331 VSS.n1330 5.2005
R4144 VSS.n239 VSS.n228 5.2005
R4145 VSS.n254 VSS.n228 5.2005
R4146 VSS.n257 VSS.n256 5.2005
R4147 VSS.n256 VSS.n255 5.2005
R4148 VSS.n227 VSS.t506 5.2005
R4149 VSS.n229 VSS.n227 5.2005
R4150 VSS.n260 VSS.n224 5.2005
R4151 VSS.n224 VSS.n223 5.2005
R4152 VSS.n264 VSS.n263 5.2005
R4153 VSS.n265 VSS.n264 5.2005
R4154 VSS.t422 VSS.n222 5.2005
R4155 VSS.n266 VSS.n222 5.2005
R4156 VSS.n269 VSS.n268 5.2005
R4157 VSS.n268 VSS.n267 5.2005
R4158 VSS.n272 VSS.n220 5.2005
R4159 VSS.n220 VSS.n219 5.2005
R4160 VSS.n1277 VSS.t345 5.2005
R4161 VSS.n1278 VSS.n1277 5.2005
R4162 VSS.n1274 VSS.n213 5.2005
R4163 VSS.n1279 VSS.n213 5.2005
R4164 VSS.n1282 VSS.n1281 5.2005
R4165 VSS.n1281 VSS.n1280 5.2005
R4166 VSS.n218 VSS.n211 5.2005
R4167 VSS.n1249 VSS.n209 5.2005
R4168 VSS.n1249 VSS.n1225 5.2005
R4169 VSS.n1248 VSS.n1226 5.2005
R4170 VSS.n1246 VSS.n1245 5.2005
R4171 VSS.n1244 VSS.n1227 5.2005
R4172 VSS.n1243 VSS.n1242 5.2005
R4173 VSS.n1241 VSS.n1228 5.2005
R4174 VSS.n1239 VSS.n1238 5.2005
R4175 VSS.n1237 VSS.n1230 5.2005
R4176 VSS.n1236 VSS.n1235 5.2005
R4177 VSS.n1251 VSS.n1250 5.2005
R4178 VSS.n1258 VSS.n1257 5.2005
R4179 VSS.n1260 VSS.n1259 5.2005
R4180 VSS.n1262 VSS.n1261 5.2005
R4181 VSS.n1264 VSS.n1263 5.2005
R4182 VSS.n1266 VSS.n1265 5.2005
R4183 VSS.n1267 VSS.n277 5.2005
R4184 VSS.n1269 VSS.n1268 5.2005
R4185 VSS.n1057 VSS.n373 5.2005
R4186 VSS.n983 VSS.n373 5.2005
R4187 VSS.t123 VSS.n293 5.2005
R4188 VSS.n311 VSS.n293 5.2005
R4189 VSS.n1157 VSS.n1156 5.2005
R4190 VSS.n1158 VSS.n1157 5.2005
R4191 VSS.t167 VSS.n300 5.2005
R4192 VSS.n1159 VSS.n300 5.2005
R4193 VSS.n310 VSS.n309 5.2005
R4194 VSS.n1160 VSS.n310 5.2005
R4195 VSS.n1192 VSS.n1163 5.2005
R4196 VSS.n1163 VSS.n1162 5.2005
R4197 VSS.n1435 VSS.n90 5.2005
R4198 VSS.n1161 VSS.n90 5.2005
R4199 VSS.n1434 VSS.n85 5.2005
R4200 VSS.n85 VSS.n84 5.2005
R4201 VSS.n1441 VSS.t7 5.2005
R4202 VSS.n1442 VSS.n1441 5.2005
R4203 VSS.n86 VSS.n83 5.2005
R4204 VSS.n1443 VSS.n83 5.2005
R4205 VSS.t79 VSS.n1445 5.2005
R4206 VSS.n1445 VSS.n1444 5.2005
R4207 VSS.n1430 VSS.n79 5.2005
R4208 VSS.n79 VSS.n78 5.2005
R4209 VSS.n1452 VSS.n1451 5.2005
R4210 VSS.n1453 VSS.n1452 5.2005
R4211 VSS.n1327 VSS.n77 5.2005
R4212 VSS.n1454 VSS.n77 5.2005
R4213 VSS.n1458 VSS.n1456 5.2005
R4214 VSS.n1456 VSS.n1455 5.2005
R4215 VSS.n1457 VSS.n71 5.2005
R4216 VSS.n71 VSS.n70 5.2005
R4217 VSS.n1466 VSS.n1465 5.2005
R4218 VSS.n1467 VSS.n1466 5.2005
R4219 VSS.n72 VSS.n69 5.2005
R4220 VSS.n1468 VSS.n69 5.2005
R4221 VSS.n1470 VSS.n59 5.2005
R4222 VSS.n1470 VSS.n1469 5.2005
R4223 VSS.n1492 VSS.n1491 5.2005
R4224 VSS.n1491 VSS.n1490 5.2005
R4225 VSS.n1489 VSS.n66 5.2005
R4226 VSS.n1488 VSS.n1487 5.2005
R4227 VSS.n1486 VSS.n1485 5.2005
R4228 VSS.n1484 VSS.n1483 5.2005
R4229 VSS.n1482 VSS.n1481 5.2005
R4230 VSS.n1480 VSS.n1479 5.2005
R4231 VSS.n1478 VSS.n1477 5.2005
R4232 VSS.n1476 VSS.n1475 5.2005
R4233 VSS.n1474 VSS.n1473 5.2005
R4234 VSS.n1472 VSS.n1471 5.2005
R4235 VSS.n1003 VSS.n978 5.2005
R4236 VSS.n984 VSS.n978 5.2005
R4237 VSS.n986 VSS.n985 5.2005
R4238 VSS.n988 VSS.n987 5.2005
R4239 VSS.n1003 VSS.n976 5.2005
R4240 VSS.n989 VSS.n976 5.2005
R4241 VSS.n991 VSS.n990 5.2005
R4242 VSS.n993 VSS.n992 5.2005
R4243 VSS.n1003 VSS.n980 5.2005
R4244 VSS.n994 VSS.n980 5.2005
R4245 VSS.n996 VSS.n995 5.2005
R4246 VSS.n998 VSS.n997 5.2005
R4247 VSS.n999 VSS.n982 5.2005
R4248 VSS.n1001 VSS.n1000 5.2005
R4249 VSS.n1057 VSS.n294 5.2005
R4250 VSS.n296 VSS.n294 5.2005
R4251 VSS.t123 VSS.n1203 5.2005
R4252 VSS.n1203 VSS.n1202 5.2005
R4253 VSS.n1156 VSS.n295 5.2005
R4254 VSS.n1201 VSS.n295 5.2005
R4255 VSS.n1199 VSS.t167 5.2005
R4256 VSS.n1200 VSS.n1199 5.2005
R4257 VSS.n309 VSS.n298 5.2005
R4258 VSS.n298 VSS.n297 5.2005
R4259 VSS.n1192 VSS.n89 5.2005
R4260 VSS.n89 VSS.n88 5.2005
R4261 VSS.n1436 VSS.n1435 5.2005
R4262 VSS.n1437 VSS.n1436 5.2005
R4263 VSS.n1434 VSS.n87 5.2005
R4264 VSS.n1438 VSS.n87 5.2005
R4265 VSS.t7 VSS.n1440 5.2005
R4266 VSS.n1440 VSS.n1439 5.2005
R4267 VSS.n86 VSS.n82 5.2005
R4268 VSS.n82 VSS.n81 5.2005
R4269 VSS.n1446 VSS.t79 5.2005
R4270 VSS.n1447 VSS.n1446 5.2005
R4271 VSS.n1430 VSS.n80 5.2005
R4272 VSS.n1448 VSS.n80 5.2005
R4273 VSS.n1451 VSS.n1450 5.2005
R4274 VSS.n1450 VSS.n1449 5.2005
R4275 VSS.n1327 VSS.n76 5.2005
R4276 VSS.n76 VSS.n75 5.2005
R4277 VSS.n1459 VSS.n1458 5.2005
R4278 VSS.n1460 VSS.n1459 5.2005
R4279 VSS.n1457 VSS.n73 5.2005
R4280 VSS.n1461 VSS.n73 5.2005
R4281 VSS.n1465 VSS.n1464 5.2005
R4282 VSS.n1464 VSS.n1463 5.2005
R4283 VSS.n74 VSS.n72 5.2005
R4284 VSS.n1462 VSS.n74 5.2005
R4285 VSS.n65 VSS.n59 5.2005
R4286 VSS.n67 VSS.n65 5.2005
R4287 VSS.n790 VSS.n789 5.2005
R4288 VSS.n791 VSS.n790 5.2005
R4289 VSS.n732 VSS.n450 5.2005
R4290 VSS.n450 VSS.n448 5.2005
R4291 VSS.n783 VSS.n761 5.2005
R4292 VSS.n769 VSS.n761 5.2005
R4293 VSS.n782 VSS.n762 5.2005
R4294 VSS.n770 VSS.n762 5.2005
R4295 VSS.n781 VSS.n763 5.2005
R4296 VSS.n771 VSS.n763 5.2005
R4297 VSS.n768 VSS.n767 5.2005
R4298 VSS.n772 VSS.n768 5.2005
R4299 VSS.n775 VSS.n774 5.2005
R4300 VSS.n774 VSS.n773 5.2005
R4301 VSS.n446 VSS.n445 5.2005
R4302 VSS.n445 VSS.n444 5.2005
R4303 VSS.n880 VSS.t500 5.2005
R4304 VSS.n881 VSS.n880 5.2005
R4305 VSS.n885 VSS.n443 5.2005
R4306 VSS.n882 VSS.n443 5.2005
R4307 VSS.t406 VSS.n884 5.2005
R4308 VSS.n884 VSS.n883 5.2005
R4309 VSS.n891 VSS.n438 5.2005
R4310 VSS.n438 VSS.n437 5.2005
R4311 VSS.n893 VSS.n892 5.2005
R4312 VSS.n894 VSS.n893 5.2005
R4313 VSS.n899 VSS.n436 5.2005
R4314 VSS.n895 VSS.n436 5.2005
R4315 VSS.n898 VSS.n897 5.2005
R4316 VSS.n897 VSS.n896 5.2005
R4317 VSS.n905 VSS.n432 5.2005
R4318 VSS.n432 VSS.n431 5.2005
R4319 VSS.n907 VSS.n906 5.2005
R4320 VSS.n908 VSS.n907 5.2005
R4321 VSS.n939 VSS.n420 5.2005
R4322 VSS.n909 VSS.n420 5.2005
R4323 VSS.n914 VSS.n913 5.2005
R4324 VSS.n914 VSS.n910 5.2005
R4325 VSS.n934 VSS.n933 5.2005
R4326 VSS.n935 VSS.n934 5.2005
R4327 VSS.n425 VSS.n424 5.2005
R4328 VSS.n931 VSS.n930 5.2005
R4329 VSS.n929 VSS.n430 5.2005
R4330 VSS.n928 VSS.n927 5.2005
R4331 VSS.n926 VSS.n925 5.2005
R4332 VSS.n924 VSS.n923 5.2005
R4333 VSS.n922 VSS.n921 5.2005
R4334 VSS.n920 VSS.n919 5.2005
R4335 VSS.n918 VSS.n917 5.2005
R4336 VSS.n916 VSS.n915 5.2005
R4337 VSS.n731 VSS.n449 5.2005
R4338 VSS.n449 VSS.n447 5.2005
R4339 VSS.n742 VSS.n741 5.2005
R4340 VSS.n743 VSS.n739 5.2005
R4341 VSS.n745 VSS.n744 5.2005
R4342 VSS.n747 VSS.n737 5.2005
R4343 VSS.n749 VSS.n748 5.2005
R4344 VSS.n750 VSS.n736 5.2005
R4345 VSS.n752 VSS.n751 5.2005
R4346 VSS.n754 VSS.n735 5.2005
R4347 VSS.n757 VSS.n756 5.2005
R4348 VSS.n758 VSS.n733 5.2005
R4349 VSS.n789 VSS.n788 5.2005
R4350 VSS.n788 VSS.n787 5.2005
R4351 VSS.n734 VSS.n732 5.2005
R4352 VSS.n786 VSS.n734 5.2005
R4353 VSS.n784 VSS.n783 5.2005
R4354 VSS.n785 VSS.n784 5.2005
R4355 VSS.n782 VSS.n760 5.2005
R4356 VSS.n760 VSS.n759 5.2005
R4357 VSS.n781 VSS.n780 5.2005
R4358 VSS.n780 VSS.n779 5.2005
R4359 VSS.n767 VSS.n764 5.2005
R4360 VSS.n778 VSS.n764 5.2005
R4361 VSS.n776 VSS.n775 5.2005
R4362 VSS.n777 VSS.n776 5.2005
R4363 VSS.n766 VSS.n446 5.2005
R4364 VSS.n766 VSS.n765 5.2005
R4365 VSS.t500 VSS.n442 5.2005
R4366 VSS.n442 VSS.n441 5.2005
R4367 VSS.n886 VSS.n885 5.2005
R4368 VSS.n887 VSS.n886 5.2005
R4369 VSS.t406 VSS.n440 5.2005
R4370 VSS.n888 VSS.n440 5.2005
R4371 VSS.n891 VSS.n890 5.2005
R4372 VSS.n890 VSS.n889 5.2005
R4373 VSS.n892 VSS.n435 5.2005
R4374 VSS.n435 VSS.n434 5.2005
R4375 VSS.n900 VSS.n899 5.2005
R4376 VSS.n901 VSS.n900 5.2005
R4377 VSS.n898 VSS.n433 5.2005
R4378 VSS.n902 VSS.n433 5.2005
R4379 VSS.n905 VSS.n904 5.2005
R4380 VSS.n904 VSS.n903 5.2005
R4381 VSS.n906 VSS.n421 5.2005
R4382 VSS.n423 VSS.n421 5.2005
R4383 VSS.n939 VSS.n938 5.2005
R4384 VSS.n938 VSS.n937 5.2005
R4385 VSS.n913 VSS.n422 5.2005
R4386 VSS.n936 VSS.n422 5.2005
R4387 VSS.n941 VSS.n419 5.2005
R4388 VSS.n419 VSS.n418 5.2005
R4389 VSS.n940 VSS.n387 5.2005
R4390 VSS.n387 VSS.n386 5.2005
R4391 VSS.n949 VSS.n948 5.2005
R4392 VSS.n950 VSS.n949 5.2005
R4393 VSS.n912 VSS.n385 5.2005
R4394 VSS.n951 VSS.n385 5.2005
R4395 VSS.n955 VSS.n954 5.2005
R4396 VSS.n954 VSS.n953 5.2005
R4397 VSS.n958 VSS.n384 5.2005
R4398 VSS.n952 VSS.n384 5.2005
R4399 VSS.n378 VSS.n377 5.2005
R4400 VSS.n377 VSS.n376 5.2005
R4401 VSS.n970 VSS.n969 5.2005
R4402 VSS.n971 VSS.n970 5.2005
R4403 VSS.n380 VSS.n375 5.2005
R4404 VSS.n972 VSS.n375 5.2005
R4405 VSS.n974 VSS.n281 5.2005
R4406 VSS.n974 VSS.n973 5.2005
R4407 VSS.n975 VSS.n282 5.2005
R4408 VSS.n975 VSS.n374 5.2005
R4409 VSS.n1005 VSS.n1004 5.2005
R4410 VSS.n1006 VSS.n1005 5.2005
R4411 VSS.n1212 VSS.n284 5.2005
R4412 VSS.n1007 VSS.n284 5.2005
R4413 VSS.n1054 VSS.n1049 5.2005
R4414 VSS.n1049 VSS.n1048 5.2005
R4415 VSS.n1206 VSS.n292 5.2005
R4416 VSS.n1047 VSS.n292 5.2005
R4417 VSS.n1045 VSS.t242 5.2005
R4418 VSS.n1046 VSS.n1045 5.2005
R4419 VSS.n1013 VSS.n312 5.2005
R4420 VSS.n1014 VSS.n1013 5.2005
R4421 VSS.n1016 VSS.n1015 5.2005
R4422 VSS.n1018 VSS.n1012 5.2005
R4423 VSS.n1021 VSS.n1020 5.2005
R4424 VSS.n1022 VSS.n1011 5.2005
R4425 VSS.n1024 VSS.n1023 5.2005
R4426 VSS.n1026 VSS.n1010 5.2005
R4427 VSS.n1028 VSS.n1027 5.2005
R4428 VSS.n1034 VSS.n1033 5.2005
R4429 VSS.n417 VSS.n394 5.2005
R4430 VSS.n412 VSS.n411 5.2005
R4431 VSS.n409 VSS.n395 5.2005
R4432 VSS.n407 VSS.n406 5.2005
R4433 VSS.n396 VSS.n393 5.2005
R4434 VSS.n405 VSS.n396 5.2005
R4435 VSS.n404 VSS.n403 5.2005
R4436 VSS.n401 VSS.n397 5.2005
R4437 VSS.n400 VSS.n398 5.2005
R4438 VSS.n392 VSS.n391 5.2005
R4439 VSS.n942 VSS.n941 5.2005
R4440 VSS.n943 VSS.n942 5.2005
R4441 VSS.n940 VSS.n389 5.2005
R4442 VSS.n944 VSS.n389 5.2005
R4443 VSS.n948 VSS.n947 5.2005
R4444 VSS.n947 VSS.n946 5.2005
R4445 VSS.n912 VSS.n390 5.2005
R4446 VSS.n945 VSS.n390 5.2005
R4447 VSS.n955 VSS.n383 5.2005
R4448 VSS.n383 VSS.n382 5.2005
R4449 VSS.n959 VSS.n958 5.2005
R4450 VSS.n960 VSS.n959 5.2005
R4451 VSS.n379 VSS.n378 5.2005
R4452 VSS.n961 VSS.n379 5.2005
R4453 VSS.n969 VSS.n968 5.2005
R4454 VSS.n968 VSS.n967 5.2005
R4455 VSS.n381 VSS.n380 5.2005
R4456 VSS.n966 VSS.n381 5.2005
R4457 VSS.n964 VSS.n281 5.2005
R4458 VSS.n965 VSS.n964 5.2005
R4459 VSS.n963 VSS.n282 5.2005
R4460 VSS.n963 VSS.n962 5.2005
R4461 VSS.n1004 VSS.n286 5.2005
R4462 VSS.n288 VSS.n286 5.2005
R4463 VSS.n1212 VSS.n1211 5.2005
R4464 VSS.n1211 VSS.n1210 5.2005
R4465 VSS.n1054 VSS.n287 5.2005
R4466 VSS.n1209 VSS.n287 5.2005
R4467 VSS.n1207 VSS.n1206 5.2005
R4468 VSS.n1208 VSS.n1207 5.2005
R4469 VSS.t242 VSS.n290 5.2005
R4470 VSS.n290 VSS.n289 5.2005
R4471 VSS.n599 VSS.n474 5.2005
R4472 VSS.n474 VSS.n473 5.2005
R4473 VSS.n674 VSS.n609 5.2005
R4474 VSS.n632 VSS.n609 5.2005
R4475 VSS.n636 VSS.n635 5.2005
R4476 VSS.n635 VSS.n634 5.2005
R4477 VSS.n668 VSS.n465 5.2005
R4478 VSS.n633 VSS.n465 5.2005
R4479 VSS.n720 VSS.n719 5.2005
R4480 VSS.n720 VSS.n464 5.2005
R4481 VSS.n722 VSS.n451 5.2005
R4482 VSS.n723 VSS.n722 5.2005
R4483 VSS.n715 VSS.n714 5.2005
R4484 VSS.n713 VSS.n712 5.2005
R4485 VSS.n711 VSS.n710 5.2005
R4486 VSS.n709 VSS.n708 5.2005
R4487 VSS.n707 VSS.n706 5.2005
R4488 VSS.n705 VSS.n704 5.2005
R4489 VSS.n703 VSS.n702 5.2005
R4490 VSS.n721 VSS.n463 5.2005
R4491 VSS.n693 VSS.n692 5.2005
R4492 VSS.n475 VSS.n472 5.2005
R4493 VSS.n679 VSS.n678 5.2005
R4494 VSS.n681 VSS.n680 5.2005
R4495 VSS.n683 VSS.n682 5.2005
R4496 VSS.n685 VSS.n684 5.2005
R4497 VSS.n686 VSS.n604 5.2005
R4498 VSS.n688 VSS.n687 5.2005
R4499 VSS.n605 VSS.n599 5.2005
R4500 VSS.n677 VSS.n605 5.2005
R4501 VSS.n675 VSS.n674 5.2005
R4502 VSS.n676 VSS.n675 5.2005
R4503 VSS.n636 VSS.n607 5.2005
R4504 VSS.n607 VSS.n606 5.2005
R4505 VSS.n668 VSS.n469 5.2005
R4506 VSS.n471 VSS.n469 5.2005
R4507 VSS.n719 VSS.n718 5.2005
R4508 VSS.n718 VSS.n717 5.2005
R4509 VSS.n470 VSS.n451 5.2005
R4510 VSS.n716 VSS.n470 5.2005
R4511 VSS.n541 VSS.n540 5.2005
R4512 VSS.n542 VSS.n541 5.2005
R4513 VSS.n513 VSS.n507 5.2005
R4514 VSS.n543 VSS.n507 5.2005
R4515 VSS.n548 VSS.n545 5.2005
R4516 VSS.n545 VSS.n544 5.2005
R4517 VSS.n502 VSS.n501 5.2005
R4518 VSS.n501 VSS.n500 5.2005
R4519 VSS.n555 VSS.n554 5.2005
R4520 VSS.n556 VSS.n555 5.2005
R4521 VSS.n503 VSS.n499 5.2005
R4522 VSS.n557 VSS.n499 5.2005
R4523 VSS.n561 VSS.n559 5.2005
R4524 VSS.n559 VSS.n558 5.2005
R4525 VSS.n560 VSS.n491 5.2005
R4526 VSS.n491 VSS.n490 5.2005
R4527 VSS.n569 VSS.n568 5.2005
R4528 VSS.n570 VSS.n569 5.2005
R4529 VSS.n494 VSS.n489 5.2005
R4530 VSS.n571 VSS.n489 5.2005
R4531 VSS.n573 VSS.n476 5.2005
R4532 VSS.n573 VSS.n572 5.2005
R4533 VSS.n595 VSS.n594 5.2005
R4534 VSS.n594 VSS.n593 5.2005
R4535 VSS.n592 VSS.n482 5.2005
R4536 VSS.n591 VSS.n590 5.2005
R4537 VSS.n589 VSS.n588 5.2005
R4538 VSS.n587 VSS.n586 5.2005
R4539 VSS.n585 VSS.n584 5.2005
R4540 VSS.n583 VSS.n582 5.2005
R4541 VSS.n581 VSS.n580 5.2005
R4542 VSS.n575 VSS.n574 5.2005
R4543 VSS.n509 VSS.n508 5.2005
R4544 VSS.n520 VSS.n519 5.2005
R4545 VSS.n526 VSS.n525 5.2005
R4546 VSS.n528 VSS.n517 5.2005
R4547 VSS.n530 VSS.n529 5.2005
R4548 VSS.n532 VSS.n531 5.2005
R4549 VSS.n533 VSS.n510 5.2005
R4550 VSS.n533 VSS.n515 5.2005
R4551 VSS.n536 VSS.n535 5.2005
R4552 VSS.n537 VSS.n514 5.2005
R4553 VSS.n540 VSS.n539 5.2005
R4554 VSS.n539 VSS.n538 5.2005
R4555 VSS.n513 VSS.n506 5.2005
R4556 VSS.n506 VSS.n505 5.2005
R4557 VSS.n549 VSS.n548 5.2005
R4558 VSS.n550 VSS.n549 5.2005
R4559 VSS.n504 VSS.n502 5.2005
R4560 VSS.n551 VSS.n504 5.2005
R4561 VSS.n554 VSS.n553 5.2005
R4562 VSS.n553 VSS.n552 5.2005
R4563 VSS.n503 VSS.n497 5.2005
R4564 VSS.n497 VSS.n496 5.2005
R4565 VSS.n562 VSS.n561 5.2005
R4566 VSS.n563 VSS.n562 5.2005
R4567 VSS.n560 VSS.n493 5.2005
R4568 VSS.n564 VSS.n493 5.2005
R4569 VSS.n568 VSS.n567 5.2005
R4570 VSS.n567 VSS.n566 5.2005
R4571 VSS.n495 VSS.n494 5.2005
R4572 VSS.n565 VSS.n495 5.2005
R4573 VSS.n481 VSS.n476 5.2005
R4574 VSS.n483 VSS.n481 5.2005
R4575 VSS.n661 VSS.n599 5.2005
R4576 VSS.n662 VSS.n661 5.2005
R4577 VSS.n674 VSS.n610 5.2005
R4578 VSS.n663 VSS.n610 5.2005
R4579 VSS.n637 VSS.n636 5.2005
R4580 VSS.n664 VSS.n637 5.2005
R4581 VSS.n668 VSS.n667 5.2005
R4582 VSS.n667 VSS.n666 5.2005
R4583 VSS.n719 VSS.n467 5.2005
R4584 VSS.n665 VSS.n467 5.2005
R4585 VSS.n460 VSS.n451 5.2005
R4586 VSS.n462 VSS.n460 5.2005
R4587 VSS.n626 VSS.n625 5.2005
R4588 VSS.n624 VSS.n623 5.2005
R4589 VSS.n622 VSS.n621 5.2005
R4590 VSS.n620 VSS.n619 5.2005
R4591 VSS.n618 VSS.n617 5.2005
R4592 VSS.n616 VSS.n615 5.2005
R4593 VSS.n614 VSS.n459 5.2005
R4594 VSS.n728 VSS.n727 5.2005
R4595 VSS.n660 VSS.n659 5.2005
R4596 VSS.n651 VSS.n650 5.2005
R4597 VSS.n649 VSS.n648 5.2005
R4598 VSS.n647 VSS.n646 5.2005
R4599 VSS.n645 VSS.n644 5.2005
R4600 VSS.n643 VSS.n642 5.2005
R4601 VSS.n641 VSS.n640 5.2005
R4602 VSS.n639 VSS.n638 5.2005
R4603 VSS.n611 VSS.n599 5.2005
R4604 VSS.n613 VSS.n611 5.2005
R4605 VSS.n674 VSS.n673 5.2005
R4606 VSS.n673 VSS.n672 5.2005
R4607 VSS.n636 VSS.n612 5.2005
R4608 VSS.n671 VSS.n612 5.2005
R4609 VSS.n669 VSS.n668 5.2005
R4610 VSS.n670 VSS.n669 5.2005
R4611 VSS.n719 VSS.n468 5.2005
R4612 VSS.n629 VSS.n468 5.2005
R4613 VSS.n627 VSS.n451 5.2005
R4614 VSS.n628 VSS.n627 5.2005
R4615 VSS.t131 VSS.n356 5.2005
R4616 VSS.n1068 VSS.n356 5.2005
R4617 VSS.n1088 VSS.n347 5.2005
R4618 VSS.n1067 VSS.n347 5.2005
R4619 VSS.n1065 VSS.n1064 5.2005
R4620 VSS.n1066 VSS.n1065 5.2005
R4621 VSS.n1041 VSS.n366 5.2005
R4622 VSS.n366 VSS.n365 5.2005
R4623 VSS.n1156 VSS.n313 5.2005
R4624 VSS.n364 VSS.n313 5.2005
R4625 VSS.n1132 VSS.n326 5.2005
R4626 VSS.n328 VSS.n326 5.2005
R4627 VSS.n1152 VSS.n1151 5.2005
R4628 VSS.n1149 VSS.n320 5.2005
R4629 VSS.n1148 VSS.n322 5.2005
R4630 VSS.n1146 VSS.n1145 5.2005
R4631 VSS.n1144 VSS.n323 5.2005
R4632 VSS.n1143 VSS.n1142 5.2005
R4633 VSS.n1141 VSS.n324 5.2005
R4634 VSS.n1139 VSS.n1138 5.2005
R4635 VSS.n1070 VSS.n1069 5.2005
R4636 VSS.n1072 VSS.n354 5.2005
R4637 VSS.n1074 VSS.n1073 5.2005
R4638 VSS.n1075 VSS.n353 5.2005
R4639 VSS.n1077 VSS.n1076 5.2005
R4640 VSS.n1079 VSS.n352 5.2005
R4641 VSS.n1080 VSS.n351 5.2005
R4642 VSS.n1083 VSS.n1082 5.2005
R4643 VSS.t131 VSS.n349 5.2005
R4644 VSS.n1084 VSS.n349 5.2005
R4645 VSS.n1088 VSS.n1087 5.2005
R4646 VSS.n1087 VSS.n1086 5.2005
R4647 VSS.n1064 VSS.n350 5.2005
R4648 VSS.n1085 VSS.n350 5.2005
R4649 VSS.n1041 VSS.n317 5.2005
R4650 VSS.n319 VSS.n317 5.2005
R4651 VSS.n1156 VSS.n1155 5.2005
R4652 VSS.n1155 VSS.n1154 5.2005
R4653 VSS.n1132 VSS.n318 5.2005
R4654 VSS.n1153 VSS.n318 5.2005
R4655 VSS.t131 VSS.n340 5.2005
R4656 VSS.n340 VSS.n339 5.2005
R4657 VSS.n1088 VSS.n348 5.2005
R4658 VSS.n1035 VSS.n348 5.2005
R4659 VSS.n1064 VSS.n367 5.2005
R4660 VSS.n1036 VSS.n367 5.2005
R4661 VSS.n1041 VSS.n1038 5.2005
R4662 VSS.n1038 VSS.n1037 5.2005
R4663 VSS.n1156 VSS.n314 5.2005
R4664 VSS.n330 VSS.n314 5.2005
R4665 VSS.n1133 VSS.n1132 5.2005
R4666 VSS.n1134 VSS.n1133 5.2005
R4667 VSS.n1129 VSS.n333 5.2005
R4668 VSS.n1128 VSS.n1127 5.2005
R4669 VSS.n1126 VSS.n335 5.2005
R4670 VSS.n1124 VSS.n1123 5.2005
R4671 VSS.n1122 VSS.n337 5.2005
R4672 VSS.n1121 VSS.n1120 5.2005
R4673 VSS.n1119 VSS.n1116 5.2005
R4674 VSS.n331 VSS.n329 5.2005
R4675 VSS.n1107 VSS.n1106 5.2005
R4676 VSS.n1104 VSS.n338 5.2005
R4677 VSS.n1103 VSS.n341 5.2005
R4678 VSS.n1101 VSS.n1100 5.2005
R4679 VSS.n1099 VSS.n342 5.2005
R4680 VSS.n1098 VSS.n1097 5.2005
R4681 VSS.n1095 VSS.n343 5.2005
R4682 VSS.n1093 VSS.n1092 5.2005
R4683 VSS.t131 VSS.n344 5.2005
R4684 VSS.n1091 VSS.n344 5.2005
R4685 VSS.n1089 VSS.n1088 5.2005
R4686 VSS.n1090 VSS.n1089 5.2005
R4687 VSS.n1064 VSS.n346 5.2005
R4688 VSS.n346 VSS.n345 5.2005
R4689 VSS.n1041 VSS.n1040 5.2005
R4690 VSS.n1040 VSS.n1039 5.2005
R4691 VSS.n1156 VSS.n316 5.2005
R4692 VSS.n334 VSS.n316 5.2005
R4693 VSS.n1132 VSS.n1131 5.2005
R4694 VSS.n1131 VSS.n1130 5.2005
R4695 VSS.n1166 VSS.n1164 5.2005
R4696 VSS.n1189 VSS.n1188 5.2005
R4697 VSS.n1224 VSS.n278 5.2005
R4698 VSS.n1223 VSS.n1222 5.2005
R4699 VSS.n1219 VSS.n280 5.2005
R4700 VSS.n280 VSS.n279 5.2005
R4701 VSS.t627 VSS.n283 5.2005
R4702 VSS.n370 VSS.n283 5.2005
R4703 VSS.t122 VSS.n372 5.2005
R4704 VSS.n372 VSS.n371 5.2005
R4705 VSS.n1058 VSS.n1057 5.2005
R4706 VSS.n1059 VSS.n1058 5.2005
R4707 VSS.n1051 VSS.n368 5.2005
R4708 VSS.n1060 VSS.n368 5.2005
R4709 VSS.n1064 VSS.n1063 5.2005
R4710 VSS.n1063 VSS.n1062 5.2005
R4711 VSS.n1044 VSS.n369 5.2005
R4712 VSS.n1061 VSS.n369 5.2005
R4713 VSS.n1132 VSS.n301 5.2005
R4714 VSS.n303 VSS.n301 5.2005
R4715 VSS.t167 VSS.n1198 5.2005
R4716 VSS.n1198 VSS.n1197 5.2005
R4717 VSS.n306 VSS.n302 5.2005
R4718 VSS.n1196 VSS.n302 5.2005
R4719 VSS.n1194 VSS.t584 5.2005
R4720 VSS.n1195 VSS.n1194 5.2005
R4721 VSS.t433 VSS.n305 5.2005
R4722 VSS.n305 VSS.n304 5.2005
R4723 VSS.n1187 VSS.n1165 5.2005
R4724 VSS.n1186 VSS.n1185 5.2005
R4725 VSS.n1184 VSS.n1183 5.2005
R4726 VSS.n1178 VSS.n1177 5.2005
R4727 VSS.n1176 VSS.n1175 5.2005
R4728 VSS.n1174 VSS.n1173 5.2005
R4729 VSS.n1172 VSS.n176 5.2005
R4730 VSS.n1338 VSS.n173 5.2005
R4731 VSS.n1234 VSS.n204 5.2005
R4732 VSS.n1234 VSS.n1231 5.2005
R4733 VSS.n1233 VSS.n174 5.2005
R4734 VSS.n1340 VSS.n1339 5.2005
R4735 VSS.n1514 VSS.n55 5.2005
R4736 VSS.n55 VSS.n54 5.2005
R4737 VSS.n1516 VSS.n1515 5.2005
R4738 VSS.n1517 VSS.n1516 5.2005
R4739 VSS.n56 VSS.n53 5.2005
R4740 VSS.n1518 VSS.n53 5.2005
R4741 VSS.n1521 VSS.n1520 5.2005
R4742 VSS.n1520 VSS.n1519 5.2005
R4743 VSS.n52 VSS.n42 5.2005
R4744 VSS.n42 VSS.n41 5.2005
R4745 VSS.n1527 VSS.t58 5.2005
R4746 VSS.n1528 VSS.n1527 5.2005
R4747 VSS.n43 VSS.n40 5.2005
R4748 VSS.n1529 VSS.n40 5.2005
R4749 VSS.n1532 VSS.n1531 5.2005
R4750 VSS.n1531 VSS.n1530 5.2005
R4751 VSS.n1536 VSS.n34 5.2005
R4752 VSS.n34 VSS.n33 5.2005
R4753 VSS.n1538 VSS.n1537 5.2005
R4754 VSS.n1539 VSS.n1538 5.2005
R4755 VSS.n36 VSS.n32 5.2005
R4756 VSS.n1540 VSS.n32 5.2005
R4757 VSS.n1543 VSS.n1542 5.2005
R4758 VSS.n1542 VSS.n1541 5.2005
R4759 VSS.n31 VSS.n21 5.2005
R4760 VSS.n21 VSS.n20 5.2005
R4761 VSS.n1549 VSS.t203 5.2005
R4762 VSS.n1550 VSS.n1549 5.2005
R4763 VSS.n22 VSS.n19 5.2005
R4764 VSS.n1551 VSS.n19 5.2005
R4765 VSS.n1554 VSS.n1553 5.2005
R4766 VSS.n1553 VSS.n1552 5.2005
R4767 VSS.n1555 VSS.n15 5.2005
R4768 VSS.n15 VSS.n14 5.2005
R4769 VSS.n1557 VSS.n1556 5.2005
R4770 VSS.n1558 VSS.n1557 5.2005
R4771 VSS.n13 VSS.n10 5.2005
R4772 VSS.n1559 VSS.n13 5.2005
R4773 VSS.n10 VSS.n6 5.2005
R4774 VSS.n6 VSS.n4 5.2005
R4775 VSS.n1556 VSS.n16 5.2005
R4776 VSS.n25 VSS.n16 5.2005
R4777 VSS.n1555 VSS.n17 5.2005
R4778 VSS.n26 VSS.n17 5.2005
R4779 VSS.n1554 VSS.n18 5.2005
R4780 VSS.n27 VSS.n18 5.2005
R4781 VSS.n23 VSS.n22 5.2005
R4782 VSS.n28 VSS.n23 5.2005
R4783 VSS.t203 VSS.n1548 5.2005
R4784 VSS.n1548 VSS.n1547 5.2005
R4785 VSS.n31 VSS.n24 5.2005
R4786 VSS.n1546 VSS.n24 5.2005
R4787 VSS.n1544 VSS.n1543 5.2005
R4788 VSS.n1545 VSS.n1544 5.2005
R4789 VSS.n36 VSS.n30 5.2005
R4790 VSS.n30 VSS.n29 5.2005
R4791 VSS.n1537 VSS.n37 5.2005
R4792 VSS.n46 VSS.n37 5.2005
R4793 VSS.n1536 VSS.n38 5.2005
R4794 VSS.n47 VSS.n38 5.2005
R4795 VSS.n1532 VSS.n39 5.2005
R4796 VSS.n48 VSS.n39 5.2005
R4797 VSS.n44 VSS.n43 5.2005
R4798 VSS.n49 VSS.n44 5.2005
R4799 VSS.t58 VSS.n1526 5.2005
R4800 VSS.n1526 VSS.n1525 5.2005
R4801 VSS.n52 VSS.n45 5.2005
R4802 VSS.n1524 VSS.n45 5.2005
R4803 VSS.n1522 VSS.n1521 5.2005
R4804 VSS.n1523 VSS.n1522 5.2005
R4805 VSS.n56 VSS.n51 5.2005
R4806 VSS.n51 VSS.n50 5.2005
R4807 VSS.n1515 VSS.n57 5.2005
R4808 VSS.n1498 VSS.n57 5.2005
R4809 VSS.n1514 VSS.n58 5.2005
R4810 VSS.n1499 VSS.n58 5.2005
R4811 VSS.n1513 VSS.n1512 5.2005
R4812 VSS.n1512 VSS.n1511 5.2005
R4813 VSS.n1510 VSS.n1497 5.2005
R4814 VSS.n1509 VSS.n1508 5.2005
R4815 VSS.n1507 VSS.n1506 5.2005
R4816 VSS.n1505 VSS.n1504 5.2005
R4817 VSS.n1503 VSS.n1502 5.2005
R4818 VSS.n1501 VSS.n1500 5.2005
R4819 VSS.n1572 VSS.n1571 5.2005
R4820 VSS.n7 VSS.n5 5.2005
R4821 VSS.n1561 VSS.n1560 5.2005
R4822 VSS.n1563 VSS.n1562 5.2005
R4823 VSS.n1569 VSS.n11 5.2005
R4824 VSS.n1564 VSS.n11 5.2005
R4825 VSS.n1565 VSS.n12 5.2005
R4826 VSS.n1567 VSS.n1566 5.2005
R4827 VSS.n1343 VSS.n1342 5.03058
R4828 VSS.n1193 VSS.t134 4.95782
R4829 VSS.n1576 VSS.n1575 4.9505
R4830 VSS.n1577 VSS.n0 4.86439
R4831 VSS.n1205 VSS.t94 4.73439
R4832 VSS.n236 VSS.n235 4.7005
R4833 VSS.n1576 VSS.n1 4.67813
R4834 VSS.n66 VSS.n64 4.6486
R4835 VSS.n1486 VSS.n63 4.6486
R4836 VSS.n1482 VSS.n62 4.6486
R4837 VSS.n1478 VSS.n61 4.6486
R4838 VSS.n1474 VSS.n60 4.6486
R4839 VSS.n987 VSS.n977 4.6486
R4840 VSS.n992 VSS.n979 4.6486
R4841 VSS.n995 VSS.n981 4.6486
R4842 VSS.n932 VSS.n425 4.6486
R4843 VSS.n430 VSS.n429 4.6486
R4844 VSS.n926 VSS.n428 4.6486
R4845 VSS.n922 VSS.n427 4.6486
R4846 VSS.n918 VSS.n426 4.6486
R4847 VSS.n740 VSS.n739 4.6486
R4848 VSS.n746 VSS.n745 4.6486
R4849 VSS.n738 VSS.n736 4.6486
R4850 VSS.n754 VSS.n753 4.6486
R4851 VSS.n1497 VSS.n1496 4.6486
R4852 VSS.n1507 VSS.n1495 4.6486
R4853 VSS.n1503 VSS.n1494 4.6486
R4854 VSS.n1571 VSS.n1570 4.6486
R4855 VSS.n1560 VSS.n9 4.6486
R4856 VSS.n1570 VSS.n7 4.6486
R4857 VSS.n1562 VSS.n9 4.6486
R4858 VSS.n1500 VSS.n1494 4.6486
R4859 VSS.n1504 VSS.n1495 4.6486
R4860 VSS.n1508 VSS.n1496 4.6486
R4861 VSS.n741 VSS.n740 4.6486
R4862 VSS.n747 VSS.n746 4.6486
R4863 VSS.n748 VSS.n738 4.6486
R4864 VSS.n753 VSS.n752 4.6486
R4865 VSS.n915 VSS.n426 4.6486
R4866 VSS.n919 VSS.n427 4.6486
R4867 VSS.n923 VSS.n428 4.6486
R4868 VSS.n927 VSS.n429 4.6486
R4869 VSS.n932 VSS.n931 4.6486
R4870 VSS.n985 VSS.n977 4.6486
R4871 VSS.n990 VSS.n979 4.6486
R4872 VSS.n997 VSS.n981 4.6486
R4873 VSS.n1471 VSS.n60 4.6486
R4874 VSS.n1475 VSS.n61 4.6486
R4875 VSS.n1479 VSS.n62 4.6486
R4876 VSS.n1483 VSS.n63 4.6486
R4877 VSS.n1487 VSS.n64 4.6486
R4878 VSS.n140 VSS.n138 4.59524
R4879 VSS.n360 VSS.n357 4.5005
R4880 VSS.n362 VSS.n361 4.5005
R4881 VSS.n1114 VSS.n1113 4.5005
R4882 VSS.n1111 VSS.n1109 4.5005
R4883 VSS.n1427 VSS.n91 4.5005
R4884 VSS.n1422 VSS.n1421 4.5005
R4885 VSS.n1420 VSS.n1345 4.5005
R4886 VSS.n1419 VSS.n1418 4.5005
R4887 VSS.n1347 VSS.n1346 4.5005
R4888 VSS.n1392 VSS.n1391 4.5005
R4889 VSS.n1390 VSS.n1360 4.5005
R4890 VSS.n1389 VSS.n1388 4.5005
R4891 VSS.n1382 VSS.n1361 4.5005
R4892 VSS.n1381 VSS.n1380 4.5005
R4893 VSS.n1379 VSS.n1378 4.5005
R4894 VSS.n876 VSS.n875 4.5005
R4895 VSS.n870 VSS.n793 4.5005
R4896 VSS.n869 VSS.n868 4.5005
R4897 VSS.n867 VSS.n866 4.5005
R4898 VSS.n804 VSS.n795 4.5005
R4899 VSS.n846 VSS.n845 4.5005
R4900 VSS.n844 VSS.n814 4.5005
R4901 VSS.n843 VSS.n842 4.5005
R4902 VSS.n841 VSS.n815 4.5005
R4903 VSS.n840 VSS.n839 4.5005
R4904 VSS.n838 VSS.n837 4.5005
R4905 VSS.n655 VSS.n652 4.5005
R4906 VSS.n657 VSS.n656 4.5005
R4907 VSS.n700 VSS.n699 4.5005
R4908 VSS.n697 VSS.n695 4.5005
R4909 VSS.n114 VSS.n113 4.5005
R4910 VSS.n128 VSS.n127 4.5005
R4911 VSS.n99 VSS.n98 4.5005
R4912 VSS.n157 VSS.n156 4.5005
R4913 VSS.n146 VSS.n145 4.5005
R4914 VSS.n167 VSS.n166 4.5005
R4915 VSS.n262 VSS.n261 4.48215
R4916 VSS.n225 VSS.n221 4.48215
R4917 VSS.n271 VSS.n270 4.48215
R4918 VSS.n1276 VSS.n1275 4.48215
R4919 VSS.n1272 VSS.n212 4.48215
R4920 VSS.n1432 VSS.n1429 4.47524
R4921 VSS.n878 VSS.n877 4.47524
R4922 VSS.n251 VSS.n250 4.34122
R4923 VSS.n248 VSS.n247 4.34122
R4924 VSS.n216 VSS.n210 4.34122
R4925 VSS.n1285 VSS.n207 4.34122
R4926 VSS.n1291 VSS.n205 4.34122
R4927 VSS.n247 VSS.n246 4.34122
R4928 VSS.n250 VSS.n249 4.34122
R4929 VSS.n1291 VSS.n1290 4.34122
R4930 VSS.n1286 VSS.n1285 4.34122
R4931 VSS.n214 VSS.n210 4.34122
R4932 VSS.n1248 VSS.n1247 4.34122
R4933 VSS.n1229 VSS.n1227 4.34122
R4934 VSS.n1241 VSS.n1240 4.34122
R4935 VSS.n1232 VSS.n1230 4.34122
R4936 VSS.n1250 VSS.n274 4.34122
R4937 VSS.n1259 VSS.n275 4.34122
R4938 VSS.n1263 VSS.n276 4.34122
R4939 VSS.n1270 VSS.n277 4.34122
R4940 VSS.n1017 VSS.n1016 4.34122
R4941 VSS.n1020 VSS.n1019 4.34122
R4942 VSS.n1025 VSS.n1024 4.34122
R4943 VSS.n1027 VSS.n1009 4.34122
R4944 VSS.n410 VSS.n394 4.34122
R4945 VSS.n409 VSS.n408 4.34122
R4946 VSS.n403 VSS.n402 4.34122
R4947 VSS.n400 VSS.n399 4.34122
R4948 VSS.n714 VSS.n452 4.34122
R4949 VSS.n711 VSS.n453 4.34122
R4950 VSS.n707 VSS.n454 4.34122
R4951 VSS.n703 VSS.n455 4.34122
R4952 VSS.n692 VSS.n691 4.34122
R4953 VSS.n681 VSS.n598 4.34122
R4954 VSS.n684 VSS.n597 4.34122
R4955 VSS.n689 VSS.n604 4.34122
R4956 VSS.n482 VSS.n480 4.34122
R4957 VSS.n589 VSS.n479 4.34122
R4958 VSS.n585 VSS.n478 4.34122
R4959 VSS.n581 VSS.n477 4.34122
R4960 VSS.n518 VSS.n509 4.34122
R4961 VSS.n527 VSS.n526 4.34122
R4962 VSS.n529 VSS.n516 4.34122
R4963 VSS.n535 VSS.n534 4.34122
R4964 VSS.n626 VSS.n456 4.34122
R4965 VSS.n622 VSS.n457 4.34122
R4966 VSS.n618 VSS.n458 4.34122
R4967 VSS.n729 VSS.n459 4.34122
R4968 VSS.n660 VSS.n600 4.34122
R4969 VSS.n649 VSS.n601 4.34122
R4970 VSS.n645 VSS.n602 4.34122
R4971 VSS.n641 VSS.n603 4.34122
R4972 VSS.n1151 VSS.n1150 4.34122
R4973 VSS.n1148 VSS.n1147 4.34122
R4974 VSS.n325 VSS.n323 4.34122
R4975 VSS.n1141 VSS.n1140 4.34122
R4976 VSS.n1071 VSS.n1070 4.34122
R4977 VSS.n355 VSS.n353 4.34122
R4978 VSS.n1079 VSS.n1078 4.34122
R4979 VSS.n1081 VSS.n1080 4.34122
R4980 VSS.n336 VSS.n333 4.34122
R4981 VSS.n1126 VSS.n1125 4.34122
R4982 VSS.n1117 VSS.n337 4.34122
R4983 VSS.n1119 VSS.n1118 4.34122
R4984 VSS.n1106 VSS.n1105 4.34122
R4985 VSS.n1103 VSS.n1102 4.34122
R4986 VSS.n1096 VSS.n342 4.34122
R4987 VSS.n1095 VSS.n1094 4.34122
R4988 VSS.n1190 VSS.n1164 4.34122
R4989 VSS.n1221 VSS.n278 4.34122
R4990 VSS.n1165 VSS.n178 4.34122
R4991 VSS.n1184 VSS.n179 4.34122
R4992 VSS.n1176 VSS.n180 4.34122
R4993 VSS.n1337 VSS.n176 4.34122
R4994 VSS.n1233 VSS.n175 4.34122
R4995 VSS.n1339 VSS.n175 4.34122
R4996 VSS.n1235 VSS.n1232 4.34122
R4997 VSS.n1240 VSS.n1239 4.34122
R4998 VSS.n1242 VSS.n1229 4.34122
R4999 VSS.n1247 VSS.n1246 4.34122
R5000 VSS.n1338 VSS.n1337 4.34122
R5001 VSS.n1173 VSS.n180 4.34122
R5002 VSS.n1177 VSS.n179 4.34122
R5003 VSS.n1185 VSS.n178 4.34122
R5004 VSS.n1190 VSS.n1189 4.34122
R5005 VSS.n1258 VSS.n274 4.34122
R5006 VSS.n1262 VSS.n275 4.34122
R5007 VSS.n1265 VSS.n276 4.34122
R5008 VSS.n1270 VSS.n1269 4.34122
R5009 VSS.n1222 VSS.n1221 4.34122
R5010 VSS.n1105 VSS.n1104 4.34122
R5011 VSS.n1102 VSS.n1101 4.34122
R5012 VSS.n1097 VSS.n1096 4.34122
R5013 VSS.n1094 VSS.n1093 4.34122
R5014 VSS.n1118 VSS.n331 4.34122
R5015 VSS.n1120 VSS.n1117 4.34122
R5016 VSS.n1125 VSS.n1124 4.34122
R5017 VSS.n1127 VSS.n336 4.34122
R5018 VSS.n1072 VSS.n1071 4.34122
R5019 VSS.n1073 VSS.n355 4.34122
R5020 VSS.n1078 VSS.n1077 4.34122
R5021 VSS.n1082 VSS.n1081 4.34122
R5022 VSS.n1140 VSS.n1139 4.34122
R5023 VSS.n1142 VSS.n325 4.34122
R5024 VSS.n1147 VSS.n1146 4.34122
R5025 VSS.n1150 VSS.n1149 4.34122
R5026 VSS.n650 VSS.n600 4.34122
R5027 VSS.n646 VSS.n601 4.34122
R5028 VSS.n642 VSS.n602 4.34122
R5029 VSS.n638 VSS.n603 4.34122
R5030 VSS.n729 VSS.n728 4.34122
R5031 VSS.n615 VSS.n458 4.34122
R5032 VSS.n619 VSS.n457 4.34122
R5033 VSS.n623 VSS.n456 4.34122
R5034 VSS.n519 VSS.n518 4.34122
R5035 VSS.n528 VSS.n527 4.34122
R5036 VSS.n532 VSS.n516 4.34122
R5037 VSS.n534 VSS.n514 4.34122
R5038 VSS.n574 VSS.n477 4.34122
R5039 VSS.n582 VSS.n478 4.34122
R5040 VSS.n586 VSS.n479 4.34122
R5041 VSS.n590 VSS.n480 4.34122
R5042 VSS.n691 VSS.n475 4.34122
R5043 VSS.n678 VSS.n598 4.34122
R5044 VSS.n682 VSS.n597 4.34122
R5045 VSS.n689 VSS.n688 4.34122
R5046 VSS.n721 VSS.n455 4.34122
R5047 VSS.n704 VSS.n454 4.34122
R5048 VSS.n708 VSS.n453 4.34122
R5049 VSS.n712 VSS.n452 4.34122
R5050 VSS.n411 VSS.n410 4.34122
R5051 VSS.n408 VSS.n407 4.34122
R5052 VSS.n402 VSS.n401 4.34122
R5053 VSS.n399 VSS.n392 4.34122
R5054 VSS.n1034 VSS.n1009 4.34122
R5055 VSS.n1026 VSS.n1025 4.34122
R5056 VSS.n1019 VSS.n1011 4.34122
R5057 VSS.n1018 VSS.n1017 4.34122
R5058 VSS.n1568 VSS.n12 4.20229
R5059 VSS.n1568 VSS.n1567 4.20229
R5060 VSS.n1218 VSS.n1217 4.08867
R5061 VSS.n1205 VSS.n1204 4.08867
R5062 VSS.n332 VSS.n315 4.08867
R5063 VSS.n1002 VSS.n982 3.72542
R5064 VSS.n756 VSS.n755 3.72542
R5065 VSS.n755 VSS.n733 3.72542
R5066 VSS.n1002 VSS.n1001 3.72542
R5067 VSS.n238 VSS.n226 3.6553
R5068 VSS.n259 VSS.n258 3.6553
R5069 VSS.n1458 VSS.t401 3.64196
R5070 VSS.n1458 VSS.t256 3.64196
R5071 VSS.n1451 VSS.t325 3.64196
R5072 VSS.n1451 VSS.t327 3.64196
R5073 VSS.t274 VSS.n86 3.64196
R5074 VSS.n309 VSS.t477 3.64196
R5075 VSS.t197 VSS.t284 3.64196
R5076 VSS.t284 VSS.t195 3.64196
R5077 VSS.n1156 VSS.n312 3.64196
R5078 VSS.t242 VSS.t378 3.64196
R5079 VSS.t242 VSS.t379 3.64196
R5080 VSS.t135 VSS.t125 3.64196
R5081 VSS.n1088 VSS.t618 3.64196
R5082 VSS.n1088 VSS.t619 3.64196
R5083 VSS.t144 VSS.t128 3.64196
R5084 VSS.n1057 VSS.t10 3.64196
R5085 VSS.n1212 VSS.n285 3.64196
R5086 VSS.n1219 VSS.t507 3.64196
R5087 VSS.t508 VSS.n1219 3.64196
R5088 VSS.n1220 VSS.n281 3.64196
R5089 VSS.n913 VSS.t413 3.64196
R5090 VSS.n913 VSS.t414 3.64196
R5091 VSS.n906 VSS.n393 3.64196
R5092 VSS.n898 VSS.t178 3.64196
R5093 VSS.t397 VSS.n898 3.64196
R5094 VSS.n885 VSS.t372 3.64196
R5095 VSS.n775 VSS.t560 3.64196
R5096 VSS.n775 VSS.t562 3.64196
R5097 VSS.n781 VSS.t463 3.64196
R5098 VSS.t262 VSS.n781 3.64196
R5099 VSS.t132 VSS.t346 3.64196
R5100 VSS.t347 VSS.t132 3.64196
R5101 VSS.t385 VSS.t153 3.64196
R5102 VSS.t153 VSS.t386 3.64196
R5103 VSS.n494 VSS.t28 3.64196
R5104 VSS.n494 VSS.t29 3.64196
R5105 VSS.n560 VSS.t229 3.64196
R5106 VSS.t231 VSS.n560 3.64196
R5107 VSS.n503 VSS.t100 3.64196
R5108 VSS.t101 VSS.n503 3.64196
R5109 VSS.t392 VSS.t187 3.64196
R5110 VSS.t187 VSS.t451 3.64196
R5111 VSS.n548 VSS.t610 3.64196
R5112 VSS.n548 VSS.t614 3.64196
R5113 VSS.t108 VSS.t186 3.64196
R5114 VSS.t186 VSS.t121 3.64196
R5115 VSS.n1214 VSS.n1213 3.63551
R5116 VSS.n1056 VSS.n1055 3.63551
R5117 VSS.n568 VSS.n492 3.62054
R5118 VSS.n561 VSS.n498 3.62054
R5119 VSS.n911 VSS.n388 3.54389
R5120 VSS.n957 VSS.n956 3.54389
R5121 VSS.n1216 VSS.n1215 3.54389
R5122 VSS.n1053 VSS.n1052 3.54389
R5123 VSS.n512 VSS.n511 3.49549
R5124 VSS.n547 VSS.n546 3.49549
R5125 VSS.n308 VSS.n307 3.4612
R5126 VSS.n1050 VSS.t619 3.45988
R5127 VSS.t507 VSS.n1218 2.91367
R5128 VSS.n1206 VSS.n1205 2.54952
R5129 VSS.n1204 VSS.t135 2.54952
R5130 VSS.n1217 VSS.n282 2.54952
R5131 VSS.n1429 VSS.n1428 2.25898
R5132 VSS.n877 VSS.n2 2.25898
R5133 VSS.n309 VSS.n308 2.0033
R5134 VSS.n307 VSS.n306 2.0033
R5135 VSS.n1206 VSS.n291 2.0033
R5136 VSS.n1053 VSS.n1051 2.0033
R5137 VSS.n1055 VSS.t131 2.0033
R5138 VSS.n1052 VSS.t144 2.0033
R5139 VSS.n1057 VSS.n1056 2.0033
R5140 VSS.n1215 VSS.t154 2.0033
R5141 VSS.n546 VSS.n502 2.0033
R5142 VSS.n513 VSS.n512 2.0033
R5143 VSS.t168 VSS.t327 1.82123
R5144 VSS.t190 VSS.t323 1.82123
R5145 VSS.t189 VSS.t331 1.82123
R5146 VSS.t188 VSS.t333 1.82123
R5147 VSS.t39 VSS.t329 1.82123
R5148 VSS.t38 VSS.t335 1.82123
R5149 VSS.t37 VSS.t337 1.82123
R5150 VSS.t111 VSS.t321 1.82123
R5151 VSS.t110 VSS.t339 1.82123
R5152 VSS.t109 VSS.t341 1.82123
R5153 VSS.t623 VSS.t297 1.82123
R5154 VSS.t622 VSS.t343 1.82123
R5155 VSS.n1064 VSS.t94 1.82123
R5156 VSS.t618 VSS.t126 1.82123
R5157 VSS.t10 VSS.n285 1.82123
R5158 VSS.n1003 VSS.t20 1.82123
R5159 VSS.n933 VSS.t24 1.82123
R5160 VSS.t542 VSS.t247 1.82123
R5161 VSS.t544 VSS.t246 1.82123
R5162 VSS.t540 VSS.t245 1.82123
R5163 VSS.t546 VSS.t244 1.82123
R5164 VSS.t548 VSS.t354 1.82123
R5165 VSS.t538 VSS.t353 1.82123
R5166 VSS.t536 VSS.t352 1.82123
R5167 VSS.t550 VSS.t351 1.82123
R5168 VSS.t552 VSS.t273 1.82123
R5169 VSS.t554 VSS.t272 1.82123
R5170 VSS.t556 VSS.t271 1.82123
R5171 VSS.t560 VSS.t270 1.82123
R5172 VSS.n636 VSS.t292 1.82123
R5173 VSS.n631 VSS.n608 1.79498
R5174 VSS.n630 VSS.n466 1.79498
R5175 VSS.n1050 VSS.n291 1.75086
R5176 VSS.n1043 VSS.n1042 1.75086
R5177 VSS.n1379 VSS.n1367 1.73942
R5178 VSS.n838 VSS.n826 1.73942
R5179 VSS.n308 VSS.t475 1.63916
R5180 VSS.n1052 VSS.t127 1.63916
R5181 VSS.n1056 VSS.t9 1.63916
R5182 VSS.n1213 VSS.t20 1.63916
R5183 VSS.n1214 VSS.t86 1.63916
R5184 VSS.t175 VSS.n1216 1.63916
R5185 VSS.n956 VSS.t176 1.63916
R5186 VSS.n911 VSS.t130 1.63916
R5187 VSS.n1469 VSS.n1468 1.1255
R5188 VSS.n1468 VSS.n1467 1.1255
R5189 VSS.n1467 VSS.n70 1.1255
R5190 VSS.n1455 VSS.n70 1.1255
R5191 VSS.n1455 VSS.n1454 1.1255
R5192 VSS.n1454 VSS.n1453 1.1255
R5193 VSS.n1453 VSS.n78 1.1255
R5194 VSS.n1444 VSS.n78 1.1255
R5195 VSS.n1444 VSS.n1443 1.1255
R5196 VSS.n1443 VSS.n1442 1.1255
R5197 VSS.n1442 VSS.n84 1.1255
R5198 VSS.n1161 VSS.n84 1.1255
R5199 VSS.n1162 VSS.n1161 1.1255
R5200 VSS.n1162 VSS.n1160 1.1255
R5201 VSS.n1160 VSS.n1159 1.1255
R5202 VSS.n1159 VSS.n1158 1.1255
R5203 VSS.n1158 VSS.n311 1.1255
R5204 VSS.n983 VSS.n311 1.1255
R5205 VSS.n986 VSS.n984 1.1255
R5206 VSS.n988 VSS.n986 1.1255
R5207 VSS.n989 VSS.n988 1.1255
R5208 VSS.n991 VSS.n989 1.1255
R5209 VSS.n993 VSS.n991 1.1255
R5210 VSS.n994 VSS.n993 1.1255
R5211 VSS.n996 VSS.n994 1.1255
R5212 VSS.n998 VSS.n996 1.1255
R5213 VSS.n999 VSS.n998 1.1255
R5214 VSS.n1462 VSS.n67 1.1255
R5215 VSS.n1463 VSS.n1462 1.1255
R5216 VSS.n1463 VSS.n1461 1.1255
R5217 VSS.n1461 VSS.n1460 1.1255
R5218 VSS.n1460 VSS.n75 1.1255
R5219 VSS.n1449 VSS.n75 1.1255
R5220 VSS.n1449 VSS.n1448 1.1255
R5221 VSS.n1448 VSS.n1447 1.1255
R5222 VSS.n1447 VSS.n81 1.1255
R5223 VSS.n1439 VSS.n81 1.1255
R5224 VSS.n1439 VSS.n1438 1.1255
R5225 VSS.n1438 VSS.n1437 1.1255
R5226 VSS.n1437 VSS.n88 1.1255
R5227 VSS.n297 VSS.n88 1.1255
R5228 VSS.n1200 VSS.n297 1.1255
R5229 VSS.n1201 VSS.n1200 1.1255
R5230 VSS.n1202 VSS.n1201 1.1255
R5231 VSS.n1202 VSS.n296 1.1255
R5232 VSS.n1473 VSS.n1472 1.1255
R5233 VSS.n1476 VSS.n1473 1.1255
R5234 VSS.n1477 VSS.n1476 1.1255
R5235 VSS.n1480 VSS.n1477 1.1255
R5236 VSS.n1481 VSS.n1480 1.1255
R5237 VSS.n1484 VSS.n1481 1.1255
R5238 VSS.n1485 VSS.n1484 1.1255
R5239 VSS.n1488 VSS.n1485 1.1255
R5240 VSS.n1489 VSS.n1488 1.1255
R5241 VSS.n910 VSS.n909 1.1255
R5242 VSS.n909 VSS.n908 1.1255
R5243 VSS.n908 VSS.n431 1.1255
R5244 VSS.n896 VSS.n431 1.1255
R5245 VSS.n896 VSS.n895 1.1255
R5246 VSS.n895 VSS.n894 1.1255
R5247 VSS.n894 VSS.n437 1.1255
R5248 VSS.n883 VSS.n437 1.1255
R5249 VSS.n883 VSS.n882 1.1255
R5250 VSS.n882 VSS.n881 1.1255
R5251 VSS.n881 VSS.n444 1.1255
R5252 VSS.n773 VSS.n444 1.1255
R5253 VSS.n773 VSS.n772 1.1255
R5254 VSS.n772 VSS.n771 1.1255
R5255 VSS.n771 VSS.n770 1.1255
R5256 VSS.n770 VSS.n769 1.1255
R5257 VSS.n769 VSS.n448 1.1255
R5258 VSS.n791 VSS.n448 1.1255
R5259 VSS.n917 VSS.n916 1.1255
R5260 VSS.n920 VSS.n917 1.1255
R5261 VSS.n921 VSS.n920 1.1255
R5262 VSS.n924 VSS.n921 1.1255
R5263 VSS.n925 VSS.n924 1.1255
R5264 VSS.n928 VSS.n925 1.1255
R5265 VSS.n929 VSS.n928 1.1255
R5266 VSS.n930 VSS.n929 1.1255
R5267 VSS.n930 VSS.n424 1.1255
R5268 VSS.n937 VSS.n936 1.1255
R5269 VSS.n937 VSS.n423 1.1255
R5270 VSS.n903 VSS.n423 1.1255
R5271 VSS.n903 VSS.n902 1.1255
R5272 VSS.n902 VSS.n901 1.1255
R5273 VSS.n901 VSS.n434 1.1255
R5274 VSS.n889 VSS.n434 1.1255
R5275 VSS.n889 VSS.n888 1.1255
R5276 VSS.n888 VSS.n887 1.1255
R5277 VSS.n887 VSS.n441 1.1255
R5278 VSS.n765 VSS.n441 1.1255
R5279 VSS.n777 VSS.n765 1.1255
R5280 VSS.n778 VSS.n777 1.1255
R5281 VSS.n779 VSS.n778 1.1255
R5282 VSS.n779 VSS.n759 1.1255
R5283 VSS.n785 VSS.n759 1.1255
R5284 VSS.n786 VSS.n785 1.1255
R5285 VSS.n787 VSS.n786 1.1255
R5286 VSS.n742 VSS.n447 1.1255
R5287 VSS.n743 VSS.n742 1.1255
R5288 VSS.n744 VSS.n743 1.1255
R5289 VSS.n744 VSS.n737 1.1255
R5290 VSS.n749 VSS.n737 1.1255
R5291 VSS.n750 VSS.n749 1.1255
R5292 VSS.n751 VSS.n750 1.1255
R5293 VSS.n751 VSS.n735 1.1255
R5294 VSS.n757 VSS.n735 1.1255
R5295 VSS.n1572 VSS.n5 1.1255
R5296 VSS.n1561 VSS.n5 1.1255
R5297 VSS.n1563 VSS.n1561 1.1255
R5298 VSS.n1564 VSS.n1563 1.1255
R5299 VSS.n1565 VSS.n1564 1.1255
R5300 VSS.n1499 VSS.n1498 1.1255
R5301 VSS.n1498 VSS.n50 1.1255
R5302 VSS.n1523 VSS.n50 1.1255
R5303 VSS.n1524 VSS.n1523 1.1255
R5304 VSS.n1525 VSS.n1524 1.1255
R5305 VSS.n1525 VSS.n49 1.1255
R5306 VSS.n49 VSS.n48 1.1255
R5307 VSS.n48 VSS.n47 1.1255
R5308 VSS.n47 VSS.n46 1.1255
R5309 VSS.n46 VSS.n29 1.1255
R5310 VSS.n1545 VSS.n29 1.1255
R5311 VSS.n1546 VSS.n1545 1.1255
R5312 VSS.n1547 VSS.n1546 1.1255
R5313 VSS.n1547 VSS.n28 1.1255
R5314 VSS.n28 VSS.n27 1.1255
R5315 VSS.n27 VSS.n26 1.1255
R5316 VSS.n26 VSS.n25 1.1255
R5317 VSS.n25 VSS.n4 1.1255
R5318 VSS.n1502 VSS.n1501 1.1255
R5319 VSS.n1505 VSS.n1502 1.1255
R5320 VSS.n1506 VSS.n1505 1.1255
R5321 VSS.n1509 VSS.n1506 1.1255
R5322 VSS.n1510 VSS.n1509 1.1255
R5323 VSS.n1517 VSS.n54 1.1255
R5324 VSS.n1518 VSS.n1517 1.1255
R5325 VSS.n1519 VSS.n1518 1.1255
R5326 VSS.n1519 VSS.n41 1.1255
R5327 VSS.n1528 VSS.n41 1.1255
R5328 VSS.n1529 VSS.n1528 1.1255
R5329 VSS.n1530 VSS.n1529 1.1255
R5330 VSS.n1530 VSS.n33 1.1255
R5331 VSS.n1539 VSS.n33 1.1255
R5332 VSS.n1540 VSS.n1539 1.1255
R5333 VSS.n1541 VSS.n1540 1.1255
R5334 VSS.n1541 VSS.n20 1.1255
R5335 VSS.n1550 VSS.n20 1.1255
R5336 VSS.n1551 VSS.n1550 1.1255
R5337 VSS.n1552 VSS.n1551 1.1255
R5338 VSS.n1552 VSS.n14 1.1255
R5339 VSS.n1558 VSS.n14 1.1255
R5340 VSS.n1559 VSS.n1558 1.1255
R5341 VSS.n1204 VSS.t126 1.09294
R5342 VSS.n1342 VSS.n172 0.994742
R5343 VSS.n1136 VSS.n172 0.991003
R5344 VSS.n1331 VSS.n185 0.9905
R5345 VSS.n235 VSS.n234 0.9005
R5346 VSS.n234 VSS.n233 0.9005
R5347 VSS.n233 VSS.n232 0.9005
R5348 VSS.n232 VSS.n231 0.9005
R5349 VSS.n231 VSS.n230 0.9005
R5350 VSS.n1422 VSS.n1345 0.9005
R5351 VSS.n1392 VSS.n1360 0.9005
R5352 VSS.n1388 VSS.n1382 0.9005
R5353 VSS.n1382 VSS.n1381 0.9005
R5354 VSS.n841 VSS.n840 0.9005
R5355 VSS.n842 VSS.n841 0.9005
R5356 VSS.n846 VSS.n814 0.9005
R5357 VSS.n870 VSS.n869 0.9005
R5358 VSS.n218 VSS.n217 0.878
R5359 VSS.n984 VSS.n983 0.878
R5360 VSS.n916 VSS.n910 0.878
R5361 VSS.n1501 VSS.n1499 0.878
R5362 VSS.n1427 VSS.n1426 0.8405
R5363 VSS.n875 VSS.n874 0.8405
R5364 VSS.n1179 VSS.t527 0.8195
R5365 VSS.n1179 VSS.t528 0.8195
R5366 VSS.n1180 VSS.t524 0.8195
R5367 VSS.n1180 VSS.t525 0.8195
R5368 VSS.n1395 VSS.n1392 0.8105
R5369 VSS.n847 VSS.n846 0.8105
R5370 VSS.n1368 VSS.n1367 0.799908
R5371 VSS.n827 VSS.n826 0.799908
R5372 VSS.n1408 VSS.n1407 0.7805
R5373 VSS.n865 VSS.n864 0.7805
R5374 VSS.n1306 VSS.n198 0.7655
R5375 VSS.n1223 VSS.n279 0.7655
R5376 VSS.n1166 VSS.n304 0.7655
R5377 VSS.n1069 VSS.n1068 0.7655
R5378 VSS.n1107 VSS.n339 0.7655
R5379 VSS.n662 VSS.n659 0.7655
R5380 VSS.n693 VSS.n473 0.7655
R5381 VSS.n1003 VSS.n1002 0.73879
R5382 VSS.n755 VSS.n731 0.73879
R5383 VSS.n332 VSS.t182 0.728791
R5384 VSS.t193 VSS.n315 0.728791
R5385 VSS.n1387 VSS.n1360 0.6905
R5386 VSS.n820 VSS.n814 0.6905
R5387 VSS.n1300 VSS.n198 0.6755
R5388 VSS.n1300 VSS.n1299 0.6755
R5389 VSS.n1299 VSS.n1298 0.6755
R5390 VSS.n1298 VSS.n201 0.6755
R5391 VSS.n244 VSS.n201 0.6755
R5392 VSS.n245 VSS.n244 0.6755
R5393 VSS.n245 VSS.n241 0.6755
R5394 VSS.n241 VSS.n237 0.6755
R5395 VSS.n252 VSS.n237 0.6755
R5396 VSS.n1307 VSS.n1306 0.6755
R5397 VSS.n1308 VSS.n1307 0.6755
R5398 VSS.n1308 VSS.n194 0.6755
R5399 VSS.n1314 VSS.n194 0.6755
R5400 VSS.n1315 VSS.n1314 0.6755
R5401 VSS.n1316 VSS.n1315 0.6755
R5402 VSS.n1316 VSS.n190 0.6755
R5403 VSS.n1322 VSS.n190 0.6755
R5404 VSS.n1323 VSS.n1322 0.6755
R5405 VSS.n1324 VSS.n1323 0.6755
R5406 VSS.n1324 VSS.n185 0.6755
R5407 VSS.n1332 VSS.n1331 0.6755
R5408 VSS.n1333 VSS.n1332 0.6755
R5409 VSS.n1333 VSS.n184 0.6755
R5410 VSS.n1289 VSS.n184 0.6755
R5411 VSS.n1289 VSS.n1288 0.6755
R5412 VSS.n1288 VSS.n1287 0.6755
R5413 VSS.n1287 VSS.n206 0.6755
R5414 VSS.n215 VSS.n206 0.6755
R5415 VSS.n217 VSS.n215 0.6755
R5416 VSS.n255 VSS.n254 0.6755
R5417 VSS.n255 VSS.n229 0.6755
R5418 VSS.n229 VSS.n223 0.6755
R5419 VSS.n265 VSS.n223 0.6755
R5420 VSS.n266 VSS.n265 0.6755
R5421 VSS.n267 VSS.n266 0.6755
R5422 VSS.n267 VSS.n219 0.6755
R5423 VSS.n1278 VSS.n219 0.6755
R5424 VSS.n1279 VSS.n1278 0.6755
R5425 VSS.n1280 VSS.n1279 0.6755
R5426 VSS.n1280 VSS.n218 0.6755
R5427 VSS.n1340 VSS.n174 0.6755
R5428 VSS.n1231 VSS.n174 0.6755
R5429 VSS.n1236 VSS.n1231 0.6755
R5430 VSS.n1237 VSS.n1236 0.6755
R5431 VSS.n1238 VSS.n1237 0.6755
R5432 VSS.n1238 VSS.n1228 0.6755
R5433 VSS.n1243 VSS.n1228 0.6755
R5434 VSS.n1244 VSS.n1243 0.6755
R5435 VSS.n1245 VSS.n1244 0.6755
R5436 VSS.n1245 VSS.n1226 0.6755
R5437 VSS.n1260 VSS.n1257 0.6755
R5438 VSS.n1261 VSS.n1260 0.6755
R5439 VSS.n1264 VSS.n1261 0.6755
R5440 VSS.n1266 VSS.n1264 0.6755
R5441 VSS.n1267 VSS.n1266 0.6755
R5442 VSS.n1268 VSS.n1267 0.6755
R5443 VSS.n1268 VSS.n1224 0.6755
R5444 VSS.n1224 VSS.n1223 0.6755
R5445 VSS.n1195 VSS.n304 0.6755
R5446 VSS.n1196 VSS.n1195 0.6755
R5447 VSS.n1197 VSS.n1196 0.6755
R5448 VSS.n1197 VSS.n303 0.6755
R5449 VSS.n1061 VSS.n303 0.6755
R5450 VSS.n1062 VSS.n1061 0.6755
R5451 VSS.n1062 VSS.n1060 0.6755
R5452 VSS.n1060 VSS.n1059 0.6755
R5453 VSS.n1059 VSS.n371 0.6755
R5454 VSS.n371 VSS.n370 0.6755
R5455 VSS.n1174 VSS.n1172 0.6755
R5456 VSS.n1175 VSS.n1174 0.6755
R5457 VSS.n1178 VSS.n1175 0.6755
R5458 VSS.n1186 VSS.n1183 0.6755
R5459 VSS.n1187 VSS.n1186 0.6755
R5460 VSS.n1188 VSS.n1187 0.6755
R5461 VSS.n1188 VSS.n1166 0.6755
R5462 VSS.n1143 VSS.n324 0.6755
R5463 VSS.n1144 VSS.n1143 0.6755
R5464 VSS.n1145 VSS.n1144 0.6755
R5465 VSS.n1145 VSS.n322 0.6755
R5466 VSS.n322 VSS.n320 0.6755
R5467 VSS.n1152 VSS.n320 0.6755
R5468 VSS.n1074 VSS.n354 0.6755
R5469 VSS.n1075 VSS.n1074 0.6755
R5470 VSS.n1076 VSS.n1075 0.6755
R5471 VSS.n1076 VSS.n352 0.6755
R5472 VSS.n352 VSS.n351 0.6755
R5473 VSS.n1083 VSS.n351 0.6755
R5474 VSS.n1121 VSS.n1116 0.6755
R5475 VSS.n1122 VSS.n1121 0.6755
R5476 VSS.n1123 VSS.n1122 0.6755
R5477 VSS.n1123 VSS.n335 0.6755
R5478 VSS.n1128 VSS.n335 0.6755
R5479 VSS.n1129 VSS.n1128 0.6755
R5480 VSS.n341 VSS.n338 0.6755
R5481 VSS.n1100 VSS.n341 0.6755
R5482 VSS.n1100 VSS.n1099 0.6755
R5483 VSS.n1099 VSS.n1098 0.6755
R5484 VSS.n1098 VSS.n343 0.6755
R5485 VSS.n1092 VSS.n343 0.6755
R5486 VSS.n1028 VSS.n1010 0.6755
R5487 VSS.n1023 VSS.n1010 0.6755
R5488 VSS.n1023 VSS.n1022 0.6755
R5489 VSS.n1022 VSS.n1021 0.6755
R5490 VSS.n1021 VSS.n1012 0.6755
R5491 VSS.n1015 VSS.n1012 0.6755
R5492 VSS.n1015 VSS.n1014 0.6755
R5493 VSS.n1208 VSS.n289 0.6755
R5494 VSS.n1209 VSS.n1208 0.6755
R5495 VSS.n1210 VSS.n1209 0.6755
R5496 VSS.n1210 VSS.n288 0.6755
R5497 VSS.n962 VSS.n288 0.6755
R5498 VSS.n965 VSS.n962 0.6755
R5499 VSS.n966 VSS.n965 0.6755
R5500 VSS.n967 VSS.n966 0.6755
R5501 VSS.n967 VSS.n961 0.6755
R5502 VSS.n961 VSS.n960 0.6755
R5503 VSS.n960 VSS.n382 0.6755
R5504 VSS.n945 VSS.n382 0.6755
R5505 VSS.n946 VSS.n945 0.6755
R5506 VSS.n946 VSS.n944 0.6755
R5507 VSS.n944 VSS.n943 0.6755
R5508 VSS.n412 VSS.n395 0.6755
R5509 VSS.n406 VSS.n395 0.6755
R5510 VSS.n406 VSS.n405 0.6755
R5511 VSS.n405 VSS.n404 0.6755
R5512 VSS.n404 VSS.n397 0.6755
R5513 VSS.n398 VSS.n397 0.6755
R5514 VSS.n398 VSS.n391 0.6755
R5515 VSS.n1047 VSS.n1046 0.6755
R5516 VSS.n1048 VSS.n1047 0.6755
R5517 VSS.n1048 VSS.n1007 0.6755
R5518 VSS.n1007 VSS.n1006 0.6755
R5519 VSS.n1006 VSS.n374 0.6755
R5520 VSS.n973 VSS.n374 0.6755
R5521 VSS.n973 VSS.n972 0.6755
R5522 VSS.n972 VSS.n971 0.6755
R5523 VSS.n971 VSS.n376 0.6755
R5524 VSS.n952 VSS.n376 0.6755
R5525 VSS.n953 VSS.n952 0.6755
R5526 VSS.n953 VSS.n951 0.6755
R5527 VSS.n951 VSS.n950 0.6755
R5528 VSS.n950 VSS.n386 0.6755
R5529 VSS.n418 VSS.n386 0.6755
R5530 VSS.n616 VSS.n614 0.6755
R5531 VSS.n617 VSS.n616 0.6755
R5532 VSS.n620 VSS.n617 0.6755
R5533 VSS.n621 VSS.n620 0.6755
R5534 VSS.n624 VSS.n621 0.6755
R5535 VSS.n625 VSS.n624 0.6755
R5536 VSS.n651 VSS.n648 0.6755
R5537 VSS.n648 VSS.n647 0.6755
R5538 VSS.n647 VSS.n644 0.6755
R5539 VSS.n644 VSS.n643 0.6755
R5540 VSS.n643 VSS.n640 0.6755
R5541 VSS.n640 VSS.n639 0.6755
R5542 VSS.n705 VSS.n702 0.6755
R5543 VSS.n706 VSS.n705 0.6755
R5544 VSS.n709 VSS.n706 0.6755
R5545 VSS.n710 VSS.n709 0.6755
R5546 VSS.n713 VSS.n710 0.6755
R5547 VSS.n715 VSS.n713 0.6755
R5548 VSS.n679 VSS.n472 0.6755
R5549 VSS.n680 VSS.n679 0.6755
R5550 VSS.n683 VSS.n680 0.6755
R5551 VSS.n685 VSS.n683 0.6755
R5552 VSS.n686 VSS.n685 0.6755
R5553 VSS.n687 VSS.n686 0.6755
R5554 VSS.n584 VSS.n583 0.6755
R5555 VSS.n587 VSS.n584 0.6755
R5556 VSS.n588 VSS.n587 0.6755
R5557 VSS.n591 VSS.n588 0.6755
R5558 VSS.n592 VSS.n591 0.6755
R5559 VSS.n593 VSS.n592 0.6755
R5560 VSS.n565 VSS.n483 0.6755
R5561 VSS.n566 VSS.n565 0.6755
R5562 VSS.n566 VSS.n564 0.6755
R5563 VSS.n564 VSS.n563 0.6755
R5564 VSS.n563 VSS.n496 0.6755
R5565 VSS.n552 VSS.n496 0.6755
R5566 VSS.n552 VSS.n551 0.6755
R5567 VSS.n551 VSS.n550 0.6755
R5568 VSS.n550 VSS.n505 0.6755
R5569 VSS.n538 VSS.n505 0.6755
R5570 VSS.n520 VSS.n508 0.6755
R5571 VSS.n525 VSS.n517 0.6755
R5572 VSS.n530 VSS.n517 0.6755
R5573 VSS.n531 VSS.n530 0.6755
R5574 VSS.n531 VSS.n515 0.6755
R5575 VSS.n536 VSS.n515 0.6755
R5576 VSS.n537 VSS.n536 0.6755
R5577 VSS.n572 VSS.n571 0.6755
R5578 VSS.n571 VSS.n570 0.6755
R5579 VSS.n570 VSS.n490 0.6755
R5580 VSS.n558 VSS.n490 0.6755
R5581 VSS.n558 VSS.n557 0.6755
R5582 VSS.n557 VSS.n556 0.6755
R5583 VSS.n556 VSS.n500 0.6755
R5584 VSS.n544 VSS.n500 0.6755
R5585 VSS.n544 VSS.n543 0.6755
R5586 VSS.n543 VSS.n542 0.6755
R5587 VSS.n1575 VSS.n2 0.66487
R5588 VSS.n1251 VSS.n1225 0.653
R5589 VSS.n418 VSS.n417 0.653
R5590 VSS.n1000 VSS.n296 0.653
R5591 VSS.n1490 VSS.n67 0.653
R5592 VSS.n936 VSS.n935 0.653
R5593 VSS.n787 VSS.n758 0.653
R5594 VSS.n593 VSS.n483 0.653
R5595 VSS.n1511 VSS.n54 0.653
R5596 VSS.n1566 VSS.n1559 0.653
R5597 VSS.n580 VSS.n487 0.61925
R5598 VSS.n1428 VSS.n1344 0.59737
R5599 VSS.n1378 VSS.n1363 0.5855
R5600 VSS.n837 VSS.n822 0.5855
R5601 VSS.n1032 VSS.n1028 0.563
R5602 VSS.n416 VSS.n412 0.563
R5603 VSS.n1566 VSS.n1565 0.563
R5604 VSS.n1511 VSS.n1510 0.563
R5605 VSS.n1084 VSS.n1083 0.5405
R5606 VSS.n1092 VSS.n1091 0.5405
R5607 VSS.n1014 VSS.n289 0.5405
R5608 VSS.n943 VSS.n391 0.5405
R5609 VSS.n133 VSS.n131 0.5405
R5610 VSS.n639 VSS.n613 0.5405
R5611 VSS.n687 VSS.n677 0.5405
R5612 VSS.n538 VSS.n537 0.5405
R5613 VSS.n542 VSS.n508 0.5405
R5614 VSS.n1469 VSS.n68 0.518
R5615 VSS.n792 VSS.n791 0.518
R5616 VSS.n1573 VSS.n4 0.518
R5617 VSS.n1418 VSS.n1417 0.5105
R5618 VSS.n866 VSS.n803 0.5105
R5619 VSS.n580 VSS.n579 0.50675
R5620 VSS.n1569 VSS.n1568 0.500354
R5621 VSS.n253 VSS.n252 0.47417
R5622 VSS.n1226 VSS.n1225 0.4505
R5623 VSS.n1257 VSS.n1256 0.4505
R5624 VSS.n370 VSS.n279 0.4505
R5625 VSS.n1172 VSS.n1171 0.4505
R5626 VSS.n1154 VSS.n1153 0.4505
R5627 VSS.n1154 VSS.n319 0.4505
R5628 VSS.n1085 VSS.n319 0.4505
R5629 VSS.n1086 VSS.n1085 0.4505
R5630 VSS.n1086 VSS.n1084 0.4505
R5631 VSS.n364 VSS.n328 0.4505
R5632 VSS.n365 VSS.n364 0.4505
R5633 VSS.n1066 VSS.n365 0.4505
R5634 VSS.n1067 VSS.n1066 0.4505
R5635 VSS.n1068 VSS.n1067 0.4505
R5636 VSS.n1130 VSS.n334 0.4505
R5637 VSS.n1039 VSS.n334 0.4505
R5638 VSS.n1039 VSS.n345 0.4505
R5639 VSS.n1090 VSS.n345 0.4505
R5640 VSS.n1091 VSS.n1090 0.4505
R5641 VSS.n1134 VSS.n330 0.4505
R5642 VSS.n1037 VSS.n330 0.4505
R5643 VSS.n1037 VSS.n1036 0.4505
R5644 VSS.n1036 VSS.n1035 0.4505
R5645 VSS.n1035 VSS.n339 0.4505
R5646 VSS.n629 VSS.n628 0.4505
R5647 VSS.n670 VSS.n629 0.4505
R5648 VSS.n671 VSS.n670 0.4505
R5649 VSS.n672 VSS.n671 0.4505
R5650 VSS.n672 VSS.n613 0.4505
R5651 VSS.n665 VSS.n462 0.4505
R5652 VSS.n666 VSS.n665 0.4505
R5653 VSS.n666 VSS.n664 0.4505
R5654 VSS.n664 VSS.n663 0.4505
R5655 VSS.n663 VSS.n662 0.4505
R5656 VSS.n717 VSS.n716 0.4505
R5657 VSS.n717 VSS.n471 0.4505
R5658 VSS.n606 VSS.n471 0.4505
R5659 VSS.n676 VSS.n606 0.4505
R5660 VSS.n677 VSS.n676 0.4505
R5661 VSS.n723 VSS.n464 0.4505
R5662 VSS.n633 VSS.n464 0.4505
R5663 VSS.n634 VSS.n633 0.4505
R5664 VSS.n634 VSS.n632 0.4505
R5665 VSS.n632 VSS.n473 0.4505
R5666 VSS.n250 VSS.n240 0.430889
R5667 VSS.n247 VSS.n240 0.430889
R5668 VSS.n1284 VSS.n210 0.430889
R5669 VSS.n1285 VSS.n1284 0.430889
R5670 VSS.n1292 VSS.n1291 0.430889
R5671 VSS.n1247 VSS.n209 0.430889
R5672 VSS.n1229 VSS.n209 0.430889
R5673 VSS.n1240 VSS.n209 0.430889
R5674 VSS.n1232 VSS.n209 0.430889
R5675 VSS.n1271 VSS.n274 0.430889
R5676 VSS.n1271 VSS.n275 0.430889
R5677 VSS.n1271 VSS.n276 0.430889
R5678 VSS.n1271 VSS.n1270 0.430889
R5679 VSS.n1017 VSS.n312 0.430889
R5680 VSS.n1019 VSS.n312 0.430889
R5681 VSS.n1025 VSS.n312 0.430889
R5682 VSS.n1009 VSS.n312 0.430889
R5683 VSS.n410 VSS.n393 0.430889
R5684 VSS.n408 VSS.n393 0.430889
R5685 VSS.n402 VSS.n393 0.430889
R5686 VSS.n399 VSS.n393 0.430889
R5687 VSS.n730 VSS.n452 0.430889
R5688 VSS.n730 VSS.n453 0.430889
R5689 VSS.n730 VSS.n454 0.430889
R5690 VSS.n730 VSS.n455 0.430889
R5691 VSS.n691 VSS.n690 0.430889
R5692 VSS.n690 VSS.n598 0.430889
R5693 VSS.n690 VSS.n597 0.430889
R5694 VSS.n690 VSS.n689 0.430889
R5695 VSS.n595 VSS.n480 0.430889
R5696 VSS.n595 VSS.n479 0.430889
R5697 VSS.n595 VSS.n478 0.430889
R5698 VSS.n595 VSS.n477 0.430889
R5699 VSS.n518 VSS.n510 0.430889
R5700 VSS.n527 VSS.n510 0.430889
R5701 VSS.n516 VSS.n510 0.430889
R5702 VSS.n534 VSS.n510 0.430889
R5703 VSS.n730 VSS.n456 0.430889
R5704 VSS.n730 VSS.n457 0.430889
R5705 VSS.n730 VSS.n458 0.430889
R5706 VSS.n730 VSS.n729 0.430889
R5707 VSS.n690 VSS.n600 0.430889
R5708 VSS.n690 VSS.n601 0.430889
R5709 VSS.n690 VSS.n602 0.430889
R5710 VSS.n690 VSS.n603 0.430889
R5711 VSS.n1150 VSS.n321 0.430889
R5712 VSS.n1147 VSS.n321 0.430889
R5713 VSS.n325 VSS.n321 0.430889
R5714 VSS.n1140 VSS.n321 0.430889
R5715 VSS.n1071 VSS.n285 0.430889
R5716 VSS.n355 VSS.n285 0.430889
R5717 VSS.n1078 VSS.n285 0.430889
R5718 VSS.n1081 VSS.n285 0.430889
R5719 VSS.n336 VSS.n321 0.430889
R5720 VSS.n1125 VSS.n321 0.430889
R5721 VSS.n1117 VSS.n321 0.430889
R5722 VSS.n1118 VSS.n321 0.430889
R5723 VSS.n1105 VSS.n285 0.430889
R5724 VSS.n1102 VSS.n285 0.430889
R5725 VSS.n1096 VSS.n285 0.430889
R5726 VSS.n1094 VSS.n285 0.430889
R5727 VSS.n1191 VSS.n1190 0.430889
R5728 VSS.n1221 VSS.n1220 0.430889
R5729 VSS.n1336 VSS.n178 0.430889
R5730 VSS.n1336 VSS.n179 0.430889
R5731 VSS.n1336 VSS.n180 0.430889
R5732 VSS.n1337 VSS.n1336 0.430889
R5733 VSS.n204 VSS.n175 0.430889
R5734 VSS.n95 VSS.t626 0.41
R5735 VSS.n95 VSS.t625 0.41
R5736 VSS.n130 VSS.t255 0.41
R5737 VSS.n130 VSS.t253 0.41
R5738 VSS.n132 VSS.t607 0.41
R5739 VSS.n132 VSS.t605 0.41
R5740 VSS.n163 VSS.t365 0.41
R5741 VSS.n163 VSS.t493 0.41
R5742 VSS.n1428 VSS.n1427 0.409133
R5743 VSS.n875 VSS.n2 0.409133
R5744 VSS.n1421 VSS.n91 0.4005
R5745 VSS.n1421 VSS.n1420 0.4005
R5746 VSS.n1420 VSS.n1419 0.4005
R5747 VSS.n1419 VSS.n1346 0.4005
R5748 VSS.n1391 VSS.n1346 0.4005
R5749 VSS.n1391 VSS.n1390 0.4005
R5750 VSS.n1390 VSS.n1389 0.4005
R5751 VSS.n1389 VSS.n1361 0.4005
R5752 VSS.n1380 VSS.n1361 0.4005
R5753 VSS.n1380 VSS.n1379 0.4005
R5754 VSS.n839 VSS.n838 0.4005
R5755 VSS.n839 VSS.n815 0.4005
R5756 VSS.n843 VSS.n815 0.4005
R5757 VSS.n844 VSS.n843 0.4005
R5758 VSS.n845 VSS.n844 0.4005
R5759 VSS.n845 VSS.n795 0.4005
R5760 VSS.n867 VSS.n795 0.4005
R5761 VSS.n868 VSS.n867 0.4005
R5762 VSS.n868 VSS.n793 0.4005
R5763 VSS.n876 VSS.n793 0.4005
R5764 VSS.n131 VSS.n129 0.3875
R5765 VSS.n1341 VSS.n1340 0.37175
R5766 VSS.n1137 VSS.n328 0.37175
R5767 VSS.n1135 VSS.n1134 0.37175
R5768 VSS.n1046 VSS.n1008 0.37175
R5769 VSS.n726 VSS.n462 0.37175
R5770 VSS.n724 VSS.n723 0.37175
R5771 VSS.n572 VSS.n488 0.37175
R5772 VSS.n134 VSS.n133 0.3695
R5773 VSS.n1138 VSS.n327 0.366125
R5774 VSS.n1069 VSS.n363 0.366125
R5775 VSS.n1115 VSS.n329 0.366125
R5776 VSS.n1108 VSS.n1107 0.366125
R5777 VSS.n727 VSS.n461 0.366125
R5778 VSS.n659 VSS.n658 0.366125
R5779 VSS.n701 VSS.n463 0.366125
R5780 VSS.n694 VSS.n693 0.366125
R5781 VSS.n1182 VSS.n1178 0.3605
R5782 VSS.n1472 VSS.n68 0.3605
R5783 VSS.n792 VSS.n447 0.3605
R5784 VSS.n1573 VSS.n1572 0.3605
R5785 VSS.n1000 VSS.n999 0.338
R5786 VSS.n1490 VSS.n1489 0.338
R5787 VSS.n935 VSS.n424 0.338
R5788 VSS.n758 VSS.n757 0.338
R5789 VSS.n524 VSS.n520 0.338
R5790 VSS.n525 VSS.n524 0.338
R5791 VSS.n1377 VSS.n1376 0.3305
R5792 VSS.n836 VSS.n835 0.3305
R5793 VSS.n577 VSS.t232 0.3281
R5794 VSS.n577 VSS.t234 0.3281
R5795 VSS.n576 VSS.t228 0.3281
R5796 VSS.n576 VSS.t230 0.3281
R5797 VSS.n485 VSS.t514 0.3281
R5798 VSS.n485 VSS.t515 0.3281
R5799 VSS.n484 VSS.t512 0.3281
R5800 VSS.n484 VSS.t513 0.3281
R5801 VSS.n1183 VSS.n1182 0.3155
R5802 VSS.n1153 VSS.n1152 0.3155
R5803 VSS.n1130 VSS.n1129 0.3155
R5804 VSS.n1381 VSS.n1363 0.3155
R5805 VSS.n840 VSS.n822 0.3155
R5806 VSS.n628 VSS.n625 0.3155
R5807 VSS.n716 VSS.n715 0.3155
R5808 VSS.n327 VSS.n324 0.309875
R5809 VSS.n363 VSS.n354 0.309875
R5810 VSS.n1116 VSS.n1115 0.309875
R5811 VSS.n1108 VSS.n338 0.309875
R5812 VSS.n614 VSS.n461 0.309875
R5813 VSS.n658 VSS.n651 0.309875
R5814 VSS.n702 VSS.n701 0.309875
R5815 VSS.n694 VSS.n472 0.309875
R5816 VSS.n1341 VSS.n173 0.28175
R5817 VSS.n1033 VSS.n1008 0.28175
R5818 VSS.n575 VSS.n488 0.28175
R5819 VSS.n1492 VSS.n64 0.2772
R5820 VSS.n1492 VSS.n63 0.2772
R5821 VSS.n1492 VSS.n62 0.2772
R5822 VSS.n1492 VSS.n61 0.2772
R5823 VSS.n1492 VSS.n60 0.2772
R5824 VSS.n1003 VSS.n977 0.2772
R5825 VSS.n1003 VSS.n979 0.2772
R5826 VSS.n1003 VSS.n981 0.2772
R5827 VSS.n933 VSS.n932 0.2772
R5828 VSS.n933 VSS.n429 0.2772
R5829 VSS.n933 VSS.n428 0.2772
R5830 VSS.n933 VSS.n427 0.2772
R5831 VSS.n933 VSS.n426 0.2772
R5832 VSS.n740 VSS.n731 0.2772
R5833 VSS.n746 VSS.n731 0.2772
R5834 VSS.n738 VSS.n731 0.2772
R5835 VSS.n753 VSS.n731 0.2772
R5836 VSS.n1513 VSS.n1496 0.2772
R5837 VSS.n1513 VSS.n1495 0.2772
R5838 VSS.n1513 VSS.n1494 0.2772
R5839 VSS.n1570 VSS.n1569 0.2772
R5840 VSS.n1569 VSS.n9 0.2772
R5841 VSS.n171 VSS.n168 0.2705
R5842 VSS.n168 VSS.n162 0.2705
R5843 VSS.n162 VSS.n158 0.2705
R5844 VSS.n104 VSS.n100 0.2705
R5845 VSS.n100 VSS.n94 0.2705
R5846 VSS.n148 VSS.n147 0.2345
R5847 VSS.n105 VSS.n104 0.2345
R5848 VSS.n1256 VSS.n1251 0.2255
R5849 VSS.n1171 VSS.n173 0.2255
R5850 VSS.n116 VSS.n115 0.2165
R5851 VSS.n1388 VSS.n1387 0.2105
R5852 VSS.n842 VSS.n820 0.2105
R5853 VSS.n94 VSS.n3 0.206961
R5854 VSS.n1364 VSS.t196 0.20525
R5855 VSS.n1364 VSS.t194 0.20525
R5856 VSS.n1365 VSS.t183 0.20525
R5857 VSS.n1365 VSS.t198 0.20525
R5858 VSS.n1369 VSS.t192 0.20525
R5859 VSS.n1369 VSS.t391 0.20525
R5860 VSS.n1370 VSS.t476 0.20525
R5861 VSS.n1370 VSS.t474 0.20525
R5862 VSS.n1372 VSS.t587 0.20525
R5863 VSS.n1372 VSS.t478 0.20525
R5864 VSS.n1374 VSS.t455 0.20525
R5865 VSS.n1374 VSS.t585 0.20525
R5866 VSS.n1362 VSS.t172 0.20525
R5867 VSS.n1362 VSS.t170 0.20525
R5868 VSS.n1393 VSS.t583 0.20525
R5869 VSS.n1393 VSS.t582 0.20525
R5870 VSS.n1410 VSS.t445 0.20525
R5871 VSS.n1410 VSS.t480 0.20525
R5872 VSS.n1411 VSS.t257 0.20525
R5873 VSS.n1411 VSS.t260 0.20525
R5874 VSS.n1413 VSS.t400 0.20525
R5875 VSS.n1413 VSS.t402 0.20525
R5876 VSS.n1414 VSS.t426 0.20525
R5877 VSS.n1414 VSS.t453 0.20525
R5878 VSS.n1423 VSS.t438 0.20525
R5879 VSS.n1423 VSS.t436 0.20525
R5880 VSS.n1424 VSS.t363 0.20525
R5881 VSS.n1424 VSS.t361 0.20525
R5882 VSS.n871 VSS.t449 0.20525
R5883 VSS.n871 VSS.t447 0.20525
R5884 VSS.n872 VSS.t430 0.20525
R5885 VSS.n872 VSS.t428 0.20525
R5886 VSS.n796 VSS.t468 0.20525
R5887 VSS.n796 VSS.t470 0.20525
R5888 VSS.n801 VSS.t263 0.20525
R5889 VSS.n801 VSS.t265 0.20525
R5890 VSS.n799 VSS.t357 0.20525
R5891 VSS.n799 VSS.t464 0.20525
R5892 VSS.n798 VSS.t269 0.20525
R5893 VSS.n798 VSS.t267 0.20525
R5894 VSS.n812 VSS.t460 0.20525
R5895 VSS.n812 VSS.t458 0.20525
R5896 VSS.n821 VSS.t251 0.20525
R5897 VSS.n821 VSS.t249 0.20525
R5898 VSS.n833 VSS.t472 0.20525
R5899 VSS.n833 VSS.t181 0.20525
R5900 VSS.n831 VSS.t398 0.20525
R5901 VSS.n831 VSS.t394 0.20525
R5902 VSS.n829 VSS.t359 0.20525
R5903 VSS.n829 VSS.t179 0.20525
R5904 VSS.n828 VSS.t440 0.20525
R5905 VSS.n828 VSS.t466 0.20525
R5906 VSS.n823 VSS.t236 0.20525
R5907 VSS.n823 VSS.t591 0.20525
R5908 VSS.n824 VSS.t240 0.20525
R5909 VSS.n824 VSS.t238 0.20525
R5910 VSS.n92 VSS.t488 0.20525
R5911 VSS.n92 VSS.t404 0.20525
R5912 VSS.n107 VSS.t210 0.20525
R5913 VSS.n107 VSS.t212 0.20525
R5914 VSS.n106 VSS.t36 0.20525
R5915 VSS.n106 VSS.t34 0.20525
R5916 VSS.n112 VSS.t207 0.20525
R5917 VSS.n112 VSS.t208 0.20525
R5918 VSS.n110 VSS.t205 0.20525
R5919 VSS.n110 VSS.t206 0.20525
R5920 VSS.n109 VSS.t202 0.20525
R5921 VSS.n109 VSS.t204 0.20525
R5922 VSS.n121 VSS.t221 0.20525
R5923 VSS.n121 VSS.t223 0.20525
R5924 VSS.n119 VSS.t624 0.20525
R5925 VSS.n119 VSS.t241 0.20525
R5926 VSS.n117 VSS.t597 0.20525
R5927 VSS.n117 VSS.t601 0.20525
R5928 VSS.n126 VSS.t217 0.20525
R5929 VSS.n126 VSS.t219 0.20525
R5930 VSS.n124 VSS.t213 0.20525
R5931 VSS.n124 VSS.t216 0.20525
R5932 VSS.n123 VSS.t200 0.20525
R5933 VSS.n123 VSS.t215 0.20525
R5934 VSS.n101 VSS.t141 0.20525
R5935 VSS.n101 VSS.t143 0.20525
R5936 VSS.n102 VSS.t137 0.20525
R5937 VSS.n102 VSS.t139 0.20525
R5938 VSS.n96 VSS.t118 0.20525
R5939 VSS.n96 VSS.t120 0.20525
R5940 VSS.n97 VSS.t114 0.20525
R5941 VSS.n97 VSS.t116 0.20525
R5942 VSS.n150 VSS.t59 0.20525
R5943 VSS.n150 VSS.t46 0.20525
R5944 VSS.n149 VSS.t396 0.20525
R5945 VSS.n149 VSS.t395 0.20525
R5946 VSS.n155 VSS.t56 0.20525
R5947 VSS.n155 VSS.t57 0.20525
R5948 VSS.n153 VSS.t54 0.20525
R5949 VSS.n153 VSS.t48 0.20525
R5950 VSS.n152 VSS.t44 0.20525
R5951 VSS.n152 VSS.t52 0.20525
R5952 VSS.n135 VSS.t492 0.20525
R5953 VSS.n135 VSS.t491 0.20525
R5954 VSS.n139 VSS.t61 0.20525
R5955 VSS.n139 VSS.t73 0.20525
R5956 VSS.n136 VSS.t490 0.20525
R5957 VSS.n136 VSS.t595 0.20525
R5958 VSS.n141 VSS.t69 0.20525
R5959 VSS.n141 VSS.t71 0.20525
R5960 VSS.n143 VSS.t67 0.20525
R5961 VSS.n143 VSS.t63 0.20525
R5962 VSS.n142 VSS.t50 0.20525
R5963 VSS.n142 VSS.t65 0.20525
R5964 VSS.n159 VSS.t148 0.20525
R5965 VSS.n159 VSS.t152 0.20525
R5966 VSS.n160 VSS.t146 0.20525
R5967 VSS.n160 VSS.t150 0.20525
R5968 VSS.n169 VSS.t462 0.20525
R5969 VSS.n169 VSS.t482 0.20525
R5970 VSS.n164 VSS.t420 0.20525
R5971 VSS.n164 VSS.t418 0.20525
R5972 VSS.n165 VSS.t416 0.20525
R5973 VSS.n165 VSS.t421 0.20525
R5974 VSS.n1409 VSS.n1345 0.1955
R5975 VSS.n1417 VSS.n1409 0.1955
R5976 VSS.n1376 VSS.n1368 0.1955
R5977 VSS.n835 VSS.n827 0.1955
R5978 VSS.n803 VSS.n794 0.1955
R5979 VSS.n869 VSS.n794 0.1955
R5980 VSS.n361 VSS.n360 0.189974
R5981 VSS.n1113 VSS.n1111 0.189974
R5982 VSS.n1375 VSS.n1373 0.189974
R5983 VSS.n1373 VSS.n1371 0.189974
R5984 VSS.n1403 VSS.n1401 0.189974
R5985 VSS.n1405 VSS.n1403 0.189974
R5986 VSS.n1398 VSS.n1396 0.189974
R5987 VSS.n1396 VSS.n1358 0.189974
R5988 VSS.n1358 VSS.n1356 0.189974
R5989 VSS.n1356 VSS.n1354 0.189974
R5990 VSS.n1354 VSS.n1352 0.189974
R5991 VSS.n1352 VSS.n1350 0.189974
R5992 VSS.n1416 VSS.n1415 0.189974
R5993 VSS.n1416 VSS.n1412 0.189974
R5994 VSS.n802 VSS.n800 0.189974
R5995 VSS.n802 VSS.n797 0.189974
R5996 VSS.n852 VSS.n850 0.189974
R5997 VSS.n854 VSS.n852 0.189974
R5998 VSS.n856 VSS.n854 0.189974
R5999 VSS.n858 VSS.n856 0.189974
R6000 VSS.n860 VSS.n858 0.189974
R6001 VSS.n862 VSS.n860 0.189974
R6002 VSS.n811 VSS.n809 0.189974
R6003 VSS.n809 VSS.n807 0.189974
R6004 VSS.n832 VSS.n830 0.189974
R6005 VSS.n834 VSS.n832 0.189974
R6006 VSS.n656 VSS.n655 0.189974
R6007 VSS.n699 VSS.n697 0.189974
R6008 VSS.n113 VSS.n111 0.189974
R6009 VSS.n113 VSS.n108 0.189974
R6010 VSS.n127 VSS.n125 0.189974
R6011 VSS.n127 VSS.n122 0.189974
R6012 VSS.n156 VSS.n154 0.189974
R6013 VSS.n156 VSS.n151 0.189974
R6014 VSS.n145 VSS.n144 0.189974
R6015 VSS.n145 VSS.n140 0.189974
R6016 VSS.n254 VSS.n253 0.178383
R6017 VSS.n1138 VSS.n1137 0.16925
R6018 VSS.n1135 VSS.n329 0.16925
R6019 VSS.n727 VSS.n726 0.16925
R6020 VSS.n724 VSS.n463 0.16925
R6021 VSS.n579 VSS.n575 0.16925
R6022 VSS.n1429 VSS.n91 0.167167
R6023 VSS.n877 VSS.n876 0.167167
R6024 VSS.n1378 VSS.n1377 0.1655
R6025 VSS.n837 VSS.n836 0.1655
R6026 VSS.n414 VSS.t17 0.1643
R6027 VSS.n414 VSS.t27 0.1643
R6028 VSS.n413 VSS.t23 0.1643
R6029 VSS.n413 VSS.t25 0.1643
R6030 VSS.n1030 VSS.t21 0.1643
R6031 VSS.n1030 VSS.t15 0.1643
R6032 VSS.n1029 VSS.t13 0.1643
R6033 VSS.n1029 VSS.t19 0.1643
R6034 VSS.n1383 VSS.t281 0.1643
R6035 VSS.n1383 VSS.t283 0.1643
R6036 VSS.n1384 VSS.t277 0.1643
R6037 VSS.n1384 VSS.t279 0.1643
R6038 VSS.n1348 VSS.t298 0.1643
R6039 VSS.n1348 VSS.t344 0.1643
R6040 VSS.n1349 VSS.t340 0.1643
R6041 VSS.n1349 VSS.t342 0.1643
R6042 VSS.n1351 VSS.t338 0.1643
R6043 VSS.n1351 VSS.t322 0.1643
R6044 VSS.n1353 VSS.t330 0.1643
R6045 VSS.n1353 VSS.t336 0.1643
R6046 VSS.n1355 VSS.t332 0.1643
R6047 VSS.n1355 VSS.t334 0.1643
R6048 VSS.n1357 VSS.t328 0.1643
R6049 VSS.n1357 VSS.t324 0.1643
R6050 VSS.n1359 VSS.t320 0.1643
R6051 VSS.n1359 VSS.t326 0.1643
R6052 VSS.n1397 VSS.t316 0.1643
R6053 VSS.n1397 VSS.t318 0.1643
R6054 VSS.n1404 VSS.t300 0.1643
R6055 VSS.n1404 VSS.t314 0.1643
R6056 VSS.n1402 VSS.t312 0.1643
R6057 VSS.n1402 VSS.t304 0.1643
R6058 VSS.n1400 VSS.t302 0.1643
R6059 VSS.n1400 VSS.t310 0.1643
R6060 VSS.n1399 VSS.t306 0.1643
R6061 VSS.n1399 VSS.t308 0.1643
R6062 VSS.n805 VSS.t579 0.1643
R6063 VSS.n805 VSS.t581 0.1643
R6064 VSS.n806 VSS.t573 0.1643
R6065 VSS.n806 VSS.t577 0.1643
R6066 VSS.n808 VSS.t571 0.1643
R6067 VSS.n808 VSS.t575 0.1643
R6068 VSS.n810 VSS.t568 0.1643
R6069 VSS.n810 VSS.t569 0.1643
R6070 VSS.n861 VSS.t565 0.1643
R6071 VSS.n861 VSS.t567 0.1643
R6072 VSS.n859 VSS.t563 0.1643
R6073 VSS.n859 VSS.t559 0.1643
R6074 VSS.n857 VSS.t557 0.1643
R6075 VSS.n857 VSS.t561 0.1643
R6076 VSS.n855 VSS.t553 0.1643
R6077 VSS.n855 VSS.t555 0.1643
R6078 VSS.n853 VSS.t537 0.1643
R6079 VSS.n853 VSS.t551 0.1643
R6080 VSS.n851 VSS.t549 0.1643
R6081 VSS.n851 VSS.t539 0.1643
R6082 VSS.n849 VSS.t541 0.1643
R6083 VSS.n849 VSS.t547 0.1643
R6084 VSS.n848 VSS.t543 0.1643
R6085 VSS.n848 VSS.t545 0.1643
R6086 VSS.n817 VSS.t371 0.1643
R6087 VSS.n817 VSS.t375 0.1643
R6088 VSS.n816 VSS.t367 0.1643
R6089 VSS.n816 VSS.t369 0.1643
R6090 VSS.n522 VSS.t615 0.1643
R6091 VSS.n522 VSS.t617 0.1643
R6092 VSS.n521 VSS.t613 0.1643
R6093 VSS.n521 VSS.t611 0.1643
R6094 VSS.n1167 VSS.t530 0.1643
R6095 VSS.n1167 VSS.t519 0.1643
R6096 VSS.n1169 VSS.t521 0.1643
R6097 VSS.n1169 VSS.t529 0.1643
R6098 VSS.n1252 VSS.t533 0.1643
R6099 VSS.n1252 VSS.t534 0.1643
R6100 VSS.n1253 VSS.t532 0.1643
R6101 VSS.n1253 VSS.t518 0.1643
R6102 VSS.n362 VSS.n357 0.1605
R6103 VSS.n1114 VSS.n1109 0.1605
R6104 VSS.n657 VSS.n652 0.1605
R6105 VSS.n700 VSS.n695 0.1605
R6106 VSS.n1574 VSS.n3 0.144074
R6107 VSS.n358 VSS.t93 0.137
R6108 VSS.n358 VSS.t95 0.137
R6109 VSS.n359 VSS.t89 0.137
R6110 VSS.n359 VSS.t91 0.137
R6111 VSS.n1110 VSS.t98 0.137
R6112 VSS.n1110 VSS.t99 0.137
R6113 VSS.n1112 VSS.t96 0.137
R6114 VSS.n1112 VSS.t97 0.137
R6115 VSS.n653 VSS.t295 0.137
R6116 VSS.n653 VSS.t296 0.137
R6117 VSS.n654 VSS.t291 0.137
R6118 VSS.n654 VSS.t294 0.137
R6119 VSS.n696 VSS.t290 0.137
R6120 VSS.n696 VSS.t293 0.137
R6121 VSS.n698 VSS.t288 0.137
R6122 VSS.n698 VSS.t286 0.137
R6123 VSS.n1255 VSS.n1254 0.118945
R6124 VSS.n1406 VSS.n1398 0.118921
R6125 VSS.n863 VSS.n862 0.118921
R6126 VSS.n1170 VSS.n1168 0.117954
R6127 VSS.n1033 VSS.n1032 0.113
R6128 VSS.n417 VSS.n416 0.113
R6129 VSS.n1407 VSS.n1347 0.1055
R6130 VSS.n864 VSS.n804 0.1055
R6131 VSS.n1395 VSS.n1394 0.0755
R6132 VSS.n847 VSS.n813 0.0755
R6133 VSS.n1406 VSS.n1405 0.0715526
R6134 VSS.n863 VSS.n811 0.0715526
R6135 VSS.n1426 VSS.n1422 0.0605
R6136 VSS.n874 VSS.n870 0.0605
R6137 VSS.n583 VSS.n487 0.05675
R6138 VSS.n147 VSS.n134 0.0545
R6139 VSS.n129 VSS.n116 0.0545
R6140 VSS.n1386 VSS.n1385 0.0478684
R6141 VSS.n819 VSS.n818 0.0478684
R6142 VSS VSS.n1577 0.0455
R6143 VSS.n158 VSS.n148 0.0365
R6144 VSS.n115 VSS.n105 0.0365
R6145 VSS.n1418 VSS.n1408 0.0155
R6146 VSS.n1394 VSS.n1347 0.0155
R6147 VSS.n813 VSS.n804 0.0155
R6148 VSS.n866 VSS.n865 0.0155
R6149 a_n6400_n23452.n1 a_n6400_n23452.t0 16.0839
R6150 a_n6400_n23452.n1 a_n6400_n23452.n0 12.3065
R6151 a_n6400_n23452.n2 a_n6400_n23452.n1 10.9378
R6152 a_n6400_n23452.n0 a_n6400_n23452.t3 0.1825
R6153 a_n6400_n23452.n0 a_n6400_n23452.t2 0.1825
R6154 a_n6400_n23452.n2 a_n6400_n23452.t4 0.1643
R6155 a_n6400_n23452.t1 a_n6400_n23452.n2 0.1643
R6156 a_n7157_n23500.n1 a_n7157_n23500.t4 16.0839
R6157 a_n7157_n23500.n0 a_n7157_n23500.t3 6.66284
R6158 a_n7157_n23500.n2 a_n7157_n23500.t1 6.62866
R6159 a_n7157_n23500.n0 a_n7157_n23500.t0 6.45713
R6160 a_n7157_n23500.t2 a_n7157_n23500.n2 6.42295
R6161 a_n7157_n23500.n1 a_n7157_n23500.n0 5.97129
R6162 a_n7157_n23500.n2 a_n7157_n23500.n1 4.55024
R6163 a_n10800_n23372.n0 a_n10800_n23372.t3 139.69
R6164 a_n10800_n23372.n0 a_n10800_n23372.t2 139.69
R6165 a_n10800_n23372.n1 a_n10800_n23372.n0 36.7175
R6166 a_n10800_n23372.n1 a_n10800_n23372.t0 14.2148
R6167 a_n10800_n23372.t1 a_n10800_n23372.n1 11.6368
R6168 a_n6400_n21652.n1 a_n6400_n21652.t4 16.0839
R6169 a_n6400_n21652.n2 a_n6400_n21652.n1 12.3065
R6170 a_n6400_n21652.n1 a_n6400_n21652.n0 10.9378
R6171 a_n6400_n21652.n2 a_n6400_n21652.t1 0.1825
R6172 a_n6400_n21652.t0 a_n6400_n21652.n2 0.1825
R6173 a_n6400_n21652.n0 a_n6400_n21652.t3 0.1643
R6174 a_n6400_n21652.n0 a_n6400_n21652.t2 0.1643
R6175 a_n7157_n21700.n1 a_n7157_n21700.t0 16.0839
R6176 a_n7157_n21700.n0 a_n7157_n21700.t4 6.66284
R6177 a_n7157_n21700.n2 a_n7157_n21700.t1 6.62866
R6178 a_n7157_n21700.n0 a_n7157_n21700.t3 6.45713
R6179 a_n7157_n21700.t2 a_n7157_n21700.n2 6.42295
R6180 a_n7157_n21700.n1 a_n7157_n21700.n0 5.97129
R6181 a_n7157_n21700.n2 a_n7157_n21700.n1 4.55024
R6182 a_n10800_n21572.n0 a_n10800_n21572.t3 139.69
R6183 a_n10800_n21572.n0 a_n10800_n21572.t2 139.69
R6184 a_n10800_n21572.n1 a_n10800_n21572.n0 36.7175
R6185 a_n10800_n21572.n1 a_n10800_n21572.t0 14.2148
R6186 a_n10800_n21572.t1 a_n10800_n21572.n1 11.6368
R6187 a_n6400_n19852.n1 a_n6400_n19852.t0 16.1006
R6188 a_n6400_n19852.n1 a_n6400_n19852.n0 12.3065
R6189 a_n6400_n19852.n2 a_n6400_n19852.n1 10.9378
R6190 a_n6400_n19852.n0 a_n6400_n19852.t2 0.1825
R6191 a_n6400_n19852.n0 a_n6400_n19852.t3 0.1825
R6192 a_n6400_n19852.t1 a_n6400_n19852.n2 0.1643
R6193 a_n6400_n19852.n2 a_n6400_n19852.t4 0.1643
R6194 a_n7300_n19900.n1 a_n7300_n19900.t0 16.1006
R6195 a_n7300_n19900.n0 a_n7300_n19900.t1 6.66284
R6196 a_n7300_n19900.n2 a_n7300_n19900.t2 6.62866
R6197 a_n7300_n19900.n0 a_n7300_n19900.t4 6.45713
R6198 a_n7300_n19900.t3 a_n7300_n19900.n2 6.42295
R6199 a_n7300_n19900.n1 a_n7300_n19900.n0 5.97129
R6200 a_n7300_n19900.n2 a_n7300_n19900.n1 4.55024
R6201 a_n10800_n19772.n0 a_n10800_n19772.t3 139.69
R6202 a_n10800_n19772.n0 a_n10800_n19772.t2 139.69
R6203 a_n10800_n19772.n1 a_n10800_n19772.n0 36.7175
R6204 a_n10800_n19772.n1 a_n10800_n19772.t0 14.2148
R6205 a_n10800_n19772.t1 a_n10800_n19772.n1 11.6368
R6206 a_n6400_n18052.n1 a_n6400_n18052.t0 16.1006
R6207 a_n6400_n18052.n1 a_n6400_n18052.n0 12.3065
R6208 a_n6400_n18052.n2 a_n6400_n18052.n1 10.9378
R6209 a_n6400_n18052.n0 a_n6400_n18052.t3 0.1825
R6210 a_n6400_n18052.n0 a_n6400_n18052.t4 0.1825
R6211 a_n6400_n18052.n2 a_n6400_n18052.t2 0.1643
R6212 a_n6400_n18052.t1 a_n6400_n18052.n2 0.1643
R6213 a_n7300_n18100.n1 a_n7300_n18100.t0 16.1006
R6214 a_n7300_n18100.n0 a_n7300_n18100.t2 6.66284
R6215 a_n7300_n18100.t3 a_n7300_n18100.n2 6.62866
R6216 a_n7300_n18100.n0 a_n7300_n18100.t1 6.45713
R6217 a_n7300_n18100.n2 a_n7300_n18100.t4 6.42295
R6218 a_n7300_n18100.n1 a_n7300_n18100.n0 5.97129
R6219 a_n7300_n18100.n2 a_n7300_n18100.n1 4.55024
R6220 a_n10800_n17972.n0 a_n10800_n17972.t3 139.69
R6221 a_n10800_n17972.n0 a_n10800_n17972.t2 139.69
R6222 a_n10800_n17972.n1 a_n10800_n17972.n0 36.7175
R6223 a_n10800_n17972.n1 a_n10800_n17972.t0 14.2148
R6224 a_n10800_n17972.t1 a_n10800_n17972.n1 11.6368
R6225 a_n6400_n16252.n1 a_n6400_n16252.t0 16.1006
R6226 a_n6400_n16252.n2 a_n6400_n16252.n1 12.3065
R6227 a_n6400_n16252.n1 a_n6400_n16252.n0 10.9378
R6228 a_n6400_n16252.t1 a_n6400_n16252.n2 0.1825
R6229 a_n6400_n16252.n2 a_n6400_n16252.t2 0.1825
R6230 a_n6400_n16252.n0 a_n6400_n16252.t3 0.1643
R6231 a_n6400_n16252.n0 a_n6400_n16252.t4 0.1643
R6232 a_n7300_n16300.n1 a_n7300_n16300.t2 16.1006
R6233 a_n7300_n16300.n0 a_n7300_n16300.t3 6.66284
R6234 a_n7300_n16300.n2 a_n7300_n16300.t0 6.62866
R6235 a_n7300_n16300.n0 a_n7300_n16300.t4 6.45713
R6236 a_n7300_n16300.t1 a_n7300_n16300.n2 6.42295
R6237 a_n7300_n16300.n1 a_n7300_n16300.n0 5.97129
R6238 a_n7300_n16300.n2 a_n7300_n16300.n1 4.55024
R6239 a_n10800_n16172.n0 a_n10800_n16172.t3 139.69
R6240 a_n10800_n16172.n0 a_n10800_n16172.t2 139.69
R6241 a_n10800_n16172.n1 a_n10800_n16172.n0 36.7175
R6242 a_n10800_n16172.n1 a_n10800_n16172.t0 14.2148
R6243 a_n10800_n16172.t1 a_n10800_n16172.n1 11.6368
R6244 a_n6400_n14452.n1 a_n6400_n14452.t2 16.1006
R6245 a_n6400_n14452.n2 a_n6400_n14452.n1 12.3065
R6246 a_n6400_n14452.n1 a_n6400_n14452.n0 10.9378
R6247 a_n6400_n14452.n2 a_n6400_n14452.t1 0.1825
R6248 a_n6400_n14452.t0 a_n6400_n14452.n2 0.1825
R6249 a_n6400_n14452.n0 a_n6400_n14452.t4 0.1643
R6250 a_n6400_n14452.n0 a_n6400_n14452.t3 0.1643
R6251 a_n7300_n14500.n1 a_n7300_n14500.t2 16.1006
R6252 a_n7300_n14500.n0 a_n7300_n14500.t4 6.66284
R6253 a_n7300_n14500.n2 a_n7300_n14500.t0 6.62866
R6254 a_n7300_n14500.n0 a_n7300_n14500.t3 6.45713
R6255 a_n7300_n14500.t1 a_n7300_n14500.n2 6.42295
R6256 a_n7300_n14500.n1 a_n7300_n14500.n0 5.97129
R6257 a_n7300_n14500.n2 a_n7300_n14500.n1 4.55024
R6258 a_n10800_n14372.n0 a_n10800_n14372.t3 139.69
R6259 a_n10800_n14372.n0 a_n10800_n14372.t2 139.69
R6260 a_n10800_n14372.n1 a_n10800_n14372.n0 36.7175
R6261 a_n10800_n14372.n1 a_n10800_n14372.t0 14.2148
R6262 a_n10800_n14372.t1 a_n10800_n14372.n1 11.6368
R6263 a_n6400_n12652.n1 a_n6400_n12652.t2 16.1006
R6264 a_n6400_n12652.n2 a_n6400_n12652.n1 12.3065
R6265 a_n6400_n12652.n1 a_n6400_n12652.n0 10.9378
R6266 a_n6400_n12652.t0 a_n6400_n12652.n2 0.1825
R6267 a_n6400_n12652.n2 a_n6400_n12652.t1 0.1825
R6268 a_n6400_n12652.n0 a_n6400_n12652.t4 0.1643
R6269 a_n6400_n12652.n0 a_n6400_n12652.t3 0.1643
R6270 a_n7300_n12700.n1 a_n7300_n12700.t2 16.1006
R6271 a_n7300_n12700.n0 a_n7300_n12700.t4 6.66284
R6272 a_n7300_n12700.n2 a_n7300_n12700.t0 6.62866
R6273 a_n7300_n12700.n0 a_n7300_n12700.t3 6.45713
R6274 a_n7300_n12700.t1 a_n7300_n12700.n2 6.42295
R6275 a_n7300_n12700.n1 a_n7300_n12700.n0 5.97129
R6276 a_n7300_n12700.n2 a_n7300_n12700.n1 4.55024
R6277 a_n10800_n12572.n0 a_n10800_n12572.t3 139.69
R6278 a_n10800_n12572.n0 a_n10800_n12572.t2 139.69
R6279 a_n10800_n12572.n1 a_n10800_n12572.n0 36.7175
R6280 a_n10800_n12572.n1 a_n10800_n12572.t0 14.2148
R6281 a_n10800_n12572.t1 a_n10800_n12572.n1 11.6368
R6282 a_2148_n500.n5 a_2148_n500.n3 10.5451
R6283 a_2148_n500.n5 a_2148_n500.n4 10.5451
R6284 a_2148_n500.n2 a_2148_n500.t3 6.45713
R6285 a_2148_n500.n8 a_2148_n500.n7 6.38754
R6286 a_2148_n500.n1 a_2148_n500.n0 6.29333
R6287 a_2148_n500.n6 a_2148_n500.n2 4.68405
R6288 a_2148_n500.n7 a_2148_n500.n6 2.22659
R6289 a_2148_n500.n6 a_2148_n500.n5 0.8055
R6290 a_2148_n500.n3 a_2148_n500.t2 0.3281
R6291 a_2148_n500.n3 a_2148_n500.t0 0.3281
R6292 a_2148_n500.n4 a_2148_n500.t8 0.3281
R6293 a_2148_n500.n4 a_2148_n500.t1 0.3281
R6294 a_2148_n500.n2 a_2148_n500.n1 0.189974
R6295 a_2148_n500.n8 a_2148_n500.t6 0.1643
R6296 a_2148_n500.t7 a_2148_n500.n8 0.1643
R6297 a_2148_n500.n0 a_2148_n500.t4 0.1643
R6298 a_2148_n500.n0 a_2148_n500.t5 0.1643
R6299 a_2148_n500.n7 a_2148_n500.n1 0.0928953
R6300 a_n5052_n1000.n5 a_n5052_n1000.n3 11.1933
R6301 a_n5052_n1000.n5 a_n5052_n1000.n4 11.1933
R6302 a_n5052_n1000.n2 a_n5052_n1000.t4 6.45713
R6303 a_n5052_n1000.n8 a_n5052_n1000.n7 6.38754
R6304 a_n5052_n1000.n1 a_n5052_n1000.n0 6.29333
R6305 a_n5052_n1000.n6 a_n5052_n1000.n2 4.68405
R6306 a_n5052_n1000.n7 a_n5052_n1000.n6 2.22659
R6307 a_n5052_n1000.n6 a_n5052_n1000.n5 0.5555
R6308 a_n5052_n1000.n2 a_n5052_n1000.n1 0.189974
R6309 a_n5052_n1000.t7 a_n5052_n1000.n8 0.1643
R6310 a_n5052_n1000.n8 a_n5052_n1000.t8 0.1643
R6311 a_n5052_n1000.n0 a_n5052_n1000.t5 0.1643
R6312 a_n5052_n1000.n0 a_n5052_n1000.t6 0.1643
R6313 a_n5052_n1000.n3 a_n5052_n1000.t1 0.1643
R6314 a_n5052_n1000.n3 a_n5052_n1000.t0 0.1643
R6315 a_n5052_n1000.n4 a_n5052_n1000.t3 0.1643
R6316 a_n5052_n1000.n4 a_n5052_n1000.t2 0.1643
R6317 a_n5052_n1000.n7 a_n5052_n1000.n1 0.0928953
R6318 a_n5052_2600.n3 a_n5052_2600.t7 7.27134
R6319 a_n5052_2600.n3 a_n5052_2600.t4 7.27134
R6320 a_n5052_2600.n2 a_n5052_2600.n0 6.71615
R6321 a_n5052_2600.n2 a_n5052_2600.n1 6.71615
R6322 a_n5052_2600.n4 a_n5052_2600.n3 6.31615
R6323 a_n5052_2600.n4 a_n5052_2600.t5 0.8195
R6324 a_n5052_2600.t6 a_n5052_2600.n4 0.8195
R6325 a_n5052_2600.n0 a_n5052_2600.t1 0.8195
R6326 a_n5052_2600.n0 a_n5052_2600.t0 0.8195
R6327 a_n5052_2600.n1 a_n5052_2600.t2 0.8195
R6328 a_n5052_2600.n1 a_n5052_2600.t3 0.8195
R6329 a_n5052_2600.n3 a_n5052_2600.n2 0.3955
R6330 a_5300_5958.t0 a_5300_5958.t1 26.7478
R6331 a_484_3500.t0 a_484_3500.t1 26.7478
R6332 a_n1900_5958.t0 a_n1900_5958.t1 26.7478
R6333 a_n3600_5641.n3 a_n3600_5641.t6 74.5091
R6334 a_n3600_5641.n3 a_n3600_5641.t7 74.5091
R6335 a_n3600_5641.n4 a_n3600_5641.n3 37.8057
R6336 a_n3600_5641.n1 a_n3600_5641.t1 13.0154
R6337 a_n3600_5641.n1 a_n3600_5641.t0 10.6142
R6338 a_n3600_5641.n0 a_n3600_5641.t2 7.23009
R6339 a_n3600_5641.n0 a_n3600_5641.t3 7.22685
R6340 a_n3600_5641.n5 a_n3600_5641.t4 6.55206
R6341 a_n3600_5641.t5 a_n3600_5641.n5 6.54882
R6342 a_n3600_5641.n5 a_n3600_5641.n4 2.75982
R6343 a_n3600_5641.n2 a_n3600_5641.n0 2.26891
R6344 a_n3600_5641.n2 a_n3600_5641.n1 0.425955
R6345 a_n3600_5641.n4 a_n3600_5641.n2 0.393227
R6346 a_n6572_3500.n3 a_n6572_3500.t6 74.5091
R6347 a_n6572_3500.n3 a_n6572_3500.t7 74.5091
R6348 a_n6572_3500.n4 a_n6572_3500.n3 37.5518
R6349 a_n6572_3500.n1 a_n6572_3500.t5 13.0154
R6350 a_n6572_3500.n1 a_n6572_3500.t0 10.6142
R6351 a_n6572_3500.n0 a_n6572_3500.t4 7.23009
R6352 a_n6572_3500.n0 a_n6572_3500.t3 7.22685
R6353 a_n6572_3500.t2 a_n6572_3500.n5 6.55206
R6354 a_n6572_3500.n5 a_n6572_3500.t1 6.54882
R6355 a_n6572_3500.n5 a_n6572_3500.n4 2.59618
R6356 a_n6572_3500.n2 a_n6572_3500.n0 2.26891
R6357 a_n6572_3500.n4 a_n6572_3500.n2 0.556864
R6358 a_n6572_3500.n2 a_n6572_3500.n1 0.425955
R6359 a_n6716_3500.t0 a_n6716_3500.t1 26.7478
R6360 a_n852_19400.n5 a_n852_19400.n3 10.7042
R6361 a_n852_19400.n5 a_n852_19400.n4 10.7042
R6362 a_n852_19400.t3 a_n852_19400.n7 6.77
R6363 a_n852_19400.n2 a_n852_19400.t0 6.6753
R6364 a_n852_19400.n1 a_n852_19400.n0 6.5388
R6365 a_n852_19400.n6 a_n852_19400.n2 4.63668
R6366 a_n852_19400.n7 a_n852_19400.n6 2.23814
R6367 a_n852_19400.n6 a_n852_19400.n5 0.5055
R6368 a_n852_19400.n2 a_n852_19400.n1 0.189974
R6369 a_n852_19400.n3 a_n852_19400.t5 0.1643
R6370 a_n852_19400.n3 a_n852_19400.t4 0.1643
R6371 a_n852_19400.n4 a_n852_19400.t7 0.1643
R6372 a_n852_19400.n4 a_n852_19400.t6 0.1643
R6373 a_n852_19400.n0 a_n852_19400.t1 0.137
R6374 a_n852_19400.n0 a_n852_19400.t2 0.137
R6375 a_n852_19400.n7 a_n852_19400.n1 0.0924286
R6376 a_80148_31500.n3 a_80148_31500.n1 10.5451
R6377 a_80148_31500.n3 a_80148_31500.n2 10.5451
R6378 a_80148_31500.n0 a_80148_31500.t7 6.55182
R6379 a_80148_31500.n5 a_80148_31500.t4 6.45713
R6380 a_80148_31500.n7 a_80148_31500.n6 6.29333
R6381 a_80148_31500.n5 a_80148_31500.n4 4.63668
R6382 a_80148_31500.n4 a_80148_31500.n0 2.23814
R6383 a_80148_31500.n4 a_80148_31500.n3 0.6055
R6384 a_80148_31500.n1 a_80148_31500.t0 0.3281
R6385 a_80148_31500.n1 a_80148_31500.t1 0.3281
R6386 a_80148_31500.n2 a_80148_31500.t2 0.3281
R6387 a_80148_31500.n2 a_80148_31500.t3 0.3281
R6388 a_80148_31500.n6 a_80148_31500.n5 0.189974
R6389 a_80148_31500.n7 a_80148_31500.t5 0.1643
R6390 a_80148_31500.t6 a_80148_31500.n7 0.1643
R6391 a_80148_31500.n6 a_80148_31500.n0 0.0924286
R6392 a_74148_31500.n2 a_74148_31500.n1 15.2138
R6393 a_74148_31500.n2 a_74148_31500.n0 14.8138
R6394 a_74148_31500.n3 a_74148_31500.n2 6.3955
R6395 a_74148_31500.n5 a_74148_31500.t2 6.06762
R6396 a_74148_31500.t5 a_74148_31500.n7 5.97267
R6397 a_74148_31500.n6 a_74148_31500.n4 5.64507
R6398 a_74148_31500.n7 a_74148_31500.n3 4.5005
R6399 a_74148_31500.n5 a_74148_31500.n3 2.40435
R6400 a_74148_31500.n4 a_74148_31500.t3 0.3281
R6401 a_74148_31500.n4 a_74148_31500.t4 0.3281
R6402 a_74148_31500.n0 a_74148_31500.t0 0.3281
R6403 a_74148_31500.n0 a_74148_31500.t1 0.3281
R6404 a_74148_31500.n1 a_74148_31500.t7 0.3281
R6405 a_74148_31500.n1 a_74148_31500.t6 0.3281
R6406 a_74148_31500.n7 a_74148_31500.n6 0.189974
R6407 a_74148_31500.n6 a_74148_31500.n5 0.0921777
R6408 a_72548_31500.n3 a_72548_31500.n1 19.6471
R6409 a_72548_31500.n3 a_72548_31500.n2 19.6471
R6410 a_72548_31500.n4 a_72548_31500.n3 9.3805
R6411 a_72548_31500.n0 a_72548_31500.t7 6.0679
R6412 a_72548_31500.n5 a_72548_31500.t4 5.97267
R6413 a_72548_31500.n7 a_72548_31500.n6 5.64507
R6414 a_72548_31500.n5 a_72548_31500.n4 4.68997
R6415 a_72548_31500.n4 a_72548_31500.n0 2.251
R6416 a_72548_31500.n7 a_72548_31500.t5 0.3281
R6417 a_72548_31500.t6 a_72548_31500.n7 0.3281
R6418 a_72548_31500.n1 a_72548_31500.t2 0.3281
R6419 a_72548_31500.n1 a_72548_31500.t3 0.3281
R6420 a_72548_31500.n2 a_72548_31500.t0 0.3281
R6421 a_72548_31500.n2 a_72548_31500.t1 0.3281
R6422 a_72548_31500.n6 a_72548_31500.n5 0.189974
R6423 a_72548_31500.n6 a_72548_31500.n0 0.0919091
R6424 a_75604_31500.n0 a_75604_31500.t5 74.5091
R6425 a_75604_31500.n0 a_75604_31500.t6 74.5091
R6426 a_75604_31500.n1 a_75604_31500.n0 28.89
R6427 a_75604_31500.n1 a_75604_31500.t4 12.772
R6428 a_75604_31500.t1 a_75604_31500.n4 6.0676
R6429 a_75604_31500.n2 a_75604_31500.t2 6.0676
R6430 a_75604_31500.n2 a_75604_31500.t3 6.06436
R6431 a_75604_31500.n4 a_75604_31500.t0 6.06436
R6432 a_75604_31500.n3 a_75604_31500.n2 2.56391
R6433 a_75604_31500.n4 a_75604_31500.n3 2.56391
R6434 a_75604_31500.n3 a_75604_31500.n1 0.8055
R6435 a_72404_31500.n0 a_72404_31500.t5 74.5091
R6436 a_72404_31500.n0 a_72404_31500.t6 74.5091
R6437 a_72404_31500.n1 a_72404_31500.n0 36.0728
R6438 a_72404_31500.n1 a_72404_31500.t4 12.972
R6439 a_72404_31500.n2 a_72404_31500.t3 6.0676
R6440 a_72404_31500.n4 a_72404_31500.t0 6.0676
R6441 a_72404_31500.t1 a_72404_31500.n4 6.06436
R6442 a_72404_31500.n2 a_72404_31500.t2 6.06436
R6443 a_72404_31500.n4 a_72404_31500.n3 2.56391
R6444 a_72404_31500.n3 a_72404_31500.n2 2.56391
R6445 a_72404_31500.n3 a_72404_31500.n1 0.6055
R6446 a_65148_29400.n5 a_65148_29400.n3 10.7042
R6447 a_65148_29400.n5 a_65148_29400.n4 10.7042
R6448 a_65148_29400.t3 a_65148_29400.n7 6.77
R6449 a_65148_29400.n2 a_65148_29400.t0 6.6753
R6450 a_65148_29400.n1 a_65148_29400.n0 6.5388
R6451 a_65148_29400.n6 a_65148_29400.n2 4.63668
R6452 a_65148_29400.n7 a_65148_29400.n6 2.23814
R6453 a_65148_29400.n6 a_65148_29400.n5 0.5055
R6454 a_65148_29400.n2 a_65148_29400.n1 0.189974
R6455 a_65148_29400.n3 a_65148_29400.t7 0.1643
R6456 a_65148_29400.n3 a_65148_29400.t6 0.1643
R6457 a_65148_29400.n4 a_65148_29400.t5 0.1643
R6458 a_65148_29400.n4 a_65148_29400.t4 0.1643
R6459 a_65148_29400.n0 a_65148_29400.t1 0.137
R6460 a_65148_29400.n0 a_65148_29400.t2 0.137
R6461 a_65148_29400.n7 a_65148_29400.n1 0.0924286
R6462 a_n852_28800.n5 a_n852_28800.n3 10.7042
R6463 a_n852_28800.n5 a_n852_28800.n4 10.7042
R6464 a_n852_28800.t3 a_n852_28800.n7 6.77
R6465 a_n852_28800.n2 a_n852_28800.t0 6.6753
R6466 a_n852_28800.n1 a_n852_28800.n0 6.5388
R6467 a_n852_28800.n6 a_n852_28800.n2 4.63668
R6468 a_n852_28800.n7 a_n852_28800.n6 2.23814
R6469 a_n852_28800.n6 a_n852_28800.n5 0.5055
R6470 a_n852_28800.n2 a_n852_28800.n1 0.189974
R6471 a_n852_28800.n3 a_n852_28800.t4 0.1643
R6472 a_n852_28800.n3 a_n852_28800.t7 0.1643
R6473 a_n852_28800.n4 a_n852_28800.t5 0.1643
R6474 a_n852_28800.n4 a_n852_28800.t6 0.1643
R6475 a_n852_28800.n0 a_n852_28800.t1 0.137
R6476 a_n852_28800.n0 a_n852_28800.t2 0.137
R6477 a_n852_28800.n7 a_n852_28800.n1 0.0924286
R6478 a_600_22678.n0 a_600_22678.t4 139.689
R6479 a_600_22678.n0 a_600_22678.t3 139.689
R6480 a_600_22678.n1 a_600_22678.n0 37.2961
R6481 a_600_22678.n1 a_600_22678.t2 12.557
R6482 a_600_22678.n2 a_600_22678.t0 6.0613
R6483 a_600_22678.t1 a_600_22678.n2 6.0613
R6484 a_600_22678.n2 a_600_22678.n1 2.78832
R6485 a_n1000_22678.n0 a_n1000_22678.t4 139.689
R6486 a_n1000_22678.n0 a_n1000_22678.t3 139.689
R6487 a_n1000_22678.n1 a_n1000_22678.n0 37.2961
R6488 a_n1000_22678.n1 a_n1000_22678.t0 12.557
R6489 a_n1000_22678.n2 a_n1000_22678.t1 6.0613
R6490 a_n1000_22678.t2 a_n1000_22678.n2 6.0613
R6491 a_n1000_22678.n2 a_n1000_22678.n1 2.78832
R6492 a_65148_38800.n5 a_65148_38800.n3 10.7042
R6493 a_65148_38800.n5 a_65148_38800.n4 10.7042
R6494 a_65148_38800.t3 a_65148_38800.n7 6.77
R6495 a_65148_38800.n2 a_65148_38800.t0 6.6753
R6496 a_65148_38800.n1 a_65148_38800.n0 6.5388
R6497 a_65148_38800.n6 a_65148_38800.n2 4.63668
R6498 a_65148_38800.n7 a_65148_38800.n6 2.23814
R6499 a_65148_38800.n6 a_65148_38800.n5 0.5055
R6500 a_65148_38800.n2 a_65148_38800.n1 0.189974
R6501 a_65148_38800.n3 a_65148_38800.t4 0.1643
R6502 a_65148_38800.n3 a_65148_38800.t5 0.1643
R6503 a_65148_38800.n4 a_65148_38800.t6 0.1643
R6504 a_65148_38800.n4 a_65148_38800.t7 0.1643
R6505 a_65148_38800.n0 a_65148_38800.t1 0.137
R6506 a_65148_38800.n0 a_65148_38800.t2 0.137
R6507 a_65148_38800.n7 a_65148_38800.n1 0.0924286
R6508 a_66600_32348.n0 a_66600_32348.t4 139.689
R6509 a_66600_32348.n0 a_66600_32348.t3 139.689
R6510 a_66600_32348.n1 a_66600_32348.n0 37.2961
R6511 a_66600_32348.n1 a_66600_32348.t0 12.392
R6512 a_66600_32348.n2 a_66600_32348.t1 6.0613
R6513 a_66600_32348.t2 a_66600_32348.n2 6.0613
R6514 a_66600_32348.n2 a_66600_32348.n1 2.78832
R6515 a_65000_32348.n0 a_65000_32348.t4 139.689
R6516 a_65000_32348.n0 a_65000_32348.t3 139.689
R6517 a_65000_32348.n1 a_65000_32348.n0 37.2961
R6518 a_65000_32348.n1 a_65000_32348.t2 12.392
R6519 a_65000_32348.n2 a_65000_32348.t0 6.0613
R6520 a_65000_32348.t1 a_65000_32348.n2 6.0613
R6521 a_65000_32348.n2 a_65000_32348.n1 2.78832
R6522 a_11748_41600.n5 a_11748_41600.n3 10.7791
R6523 a_11748_41600.n5 a_11748_41600.n4 10.7791
R6524 a_11748_41600.t3 a_11748_41600.n7 6.55182
R6525 a_11748_41600.n2 a_11748_41600.t0 6.45713
R6526 a_11748_41600.n1 a_11748_41600.n0 6.29333
R6527 a_11748_41600.n6 a_11748_41600.n2 4.63668
R6528 a_11748_41600.n7 a_11748_41600.n6 2.23814
R6529 a_11748_41600.n6 a_11748_41600.n5 0.3305
R6530 a_11748_41600.n3 a_11748_41600.t5 0.20525
R6531 a_11748_41600.n3 a_11748_41600.t4 0.20525
R6532 a_11748_41600.n4 a_11748_41600.t7 0.20525
R6533 a_11748_41600.n4 a_11748_41600.t6 0.20525
R6534 a_11748_41600.n2 a_11748_41600.n1 0.189974
R6535 a_11748_41600.n0 a_11748_41600.t1 0.1643
R6536 a_11748_41600.n0 a_11748_41600.t2 0.1643
R6537 a_11748_41600.n7 a_11748_41600.n1 0.0924286
R6538 a_2148_41600.n5 a_2148_41600.n3 10.7791
R6539 a_2148_41600.n5 a_2148_41600.n4 10.7791
R6540 a_2148_41600.t3 a_2148_41600.n7 6.55182
R6541 a_2148_41600.n2 a_2148_41600.t0 6.45713
R6542 a_2148_41600.n1 a_2148_41600.n0 6.29333
R6543 a_2148_41600.n6 a_2148_41600.n2 4.63668
R6544 a_2148_41600.n7 a_2148_41600.n6 2.23814
R6545 a_2148_41600.n6 a_2148_41600.n5 0.3305
R6546 a_2148_41600.n3 a_2148_41600.t7 0.20525
R6547 a_2148_41600.n3 a_2148_41600.t6 0.20525
R6548 a_2148_41600.n4 a_2148_41600.t4 0.20525
R6549 a_2148_41600.n4 a_2148_41600.t5 0.20525
R6550 a_2148_41600.n2 a_2148_41600.n1 0.189974
R6551 a_2148_41600.n0 a_2148_41600.t1 0.1643
R6552 a_2148_41600.n0 a_2148_41600.t2 0.1643
R6553 a_2148_41600.n7 a_2148_41600.n1 0.0924286
R6554 a_12148_44200.n2 a_12148_44200.n0 15.3662
R6555 a_12148_44200.n2 a_12148_44200.n1 14.5662
R6556 a_12148_44200.n3 a_12148_44200.n2 7.70696
R6557 a_12148_44200.n3 a_12148_44200.t0 5.9772
R6558 a_12148_44200.t1 a_12148_44200.n3 5.9772
R6559 a_12148_44200.n0 a_12148_44200.t5 0.2735
R6560 a_12148_44200.n0 a_12148_44200.t4 0.2735
R6561 a_12148_44200.n1 a_12148_44200.t3 0.2735
R6562 a_12148_44200.n1 a_12148_44200.t2 0.2735
R6563 a_10548_44200.n2 a_10548_44200.n0 19.8662
R6564 a_10548_44200.n2 a_10548_44200.n1 19.3329
R6565 a_10548_44200.n3 a_10548_44200.n2 11.5875
R6566 a_10548_44200.n3 a_10548_44200.t0 5.9772
R6567 a_10548_44200.t1 a_10548_44200.n3 5.9772
R6568 a_10548_44200.n1 a_10548_44200.t5 0.2735
R6569 a_10548_44200.n1 a_10548_44200.t4 0.2735
R6570 a_10548_44200.n0 a_10548_44200.t3 0.2735
R6571 a_10548_44200.n0 a_10548_44200.t2 0.2735
R6572 a_2548_44200.n2 a_2548_44200.n0 15.3662
R6573 a_2548_44200.n2 a_2548_44200.n1 14.5662
R6574 a_2548_44200.n3 a_2548_44200.n2 7.70696
R6575 a_2548_44200.n3 a_2548_44200.t5 5.9772
R6576 a_2548_44200.t4 a_2548_44200.n3 5.9772
R6577 a_2548_44200.n0 a_2548_44200.t1 0.2735
R6578 a_2548_44200.n0 a_2548_44200.t0 0.2735
R6579 a_2548_44200.n1 a_2548_44200.t3 0.2735
R6580 a_2548_44200.n1 a_2548_44200.t2 0.2735
R6581 a_948_44200.n2 a_948_44200.n0 19.8662
R6582 a_948_44200.n2 a_948_44200.n1 19.3329
R6583 a_948_44200.n3 a_948_44200.n2 11.5875
R6584 a_948_44200.n3 a_948_44200.t0 5.9772
R6585 a_948_44200.t1 a_948_44200.n3 5.9772
R6586 a_948_44200.n1 a_948_44200.t5 0.2735
R6587 a_948_44200.n1 a_948_44200.t4 0.2735
R6588 a_948_44200.n0 a_948_44200.t3 0.2735
R6589 a_948_44200.n0 a_948_44200.t2 0.2735
R6590 XRX.XFRONT.XFE_O.NTAIL.n29 XRX.XFRONT.XFE_O.NTAIL.n22 13.0309
R6591 XRX.XFRONT.XFE_O.NTAIL.n29 XRX.XFRONT.XFE_O.NTAIL.n28 11.5048
R6592 XRX.XFRONT.XFE_O.NTAIL.n41 XRX.XFRONT.XFE_O.NTAIL.n40 11.5048
R6593 XRX.XFRONT.XFE_O.NTAIL.n34 XRX.XFRONT.XFE_O.NTAIL.n33 9.03963
R6594 XRX.XFRONT.XFE_O.NTAIL.n1 XRX.XFRONT.XFE_O.NTAIL.t44 5.82877
R6595 XRX.XFRONT.XFE_O.NTAIL.n13 XRX.XFRONT.XFE_O.NTAIL.t21 5.82877
R6596 XRX.XFRONT.XFE_O.NTAIL.n33 XRX.XFRONT.XFE_O.NTAIL.t0 5.78141
R6597 XRX.XFRONT.XFE_O.NTAIL.n32 XRX.XFRONT.XFE_O.NTAIL.n30 5.66497
R6598 XRX.XFRONT.XFE_O.NTAIL.n28 XRX.XFRONT.XFE_O.NTAIL.n23 5.57485
R6599 XRX.XFRONT.XFE_O.NTAIL.n27 XRX.XFRONT.XFE_O.NTAIL.n25 5.57485
R6600 XRX.XFRONT.XFE_O.NTAIL.n40 XRX.XFRONT.XFE_O.NTAIL.n35 5.57485
R6601 XRX.XFRONT.XFE_O.NTAIL.n39 XRX.XFRONT.XFE_O.NTAIL.n37 5.57485
R6602 XRX.XFRONT.XFE_O.NTAIL.n1 XRX.XFRONT.XFE_O.NTAIL.n0 5.4755
R6603 XRX.XFRONT.XFE_O.NTAIL.n32 XRX.XFRONT.XFE_O.NTAIL.n31 5.4755
R6604 XRX.XFRONT.XFE_O.NTAIL.n3 XRX.XFRONT.XFE_O.NTAIL.n2 5.4755
R6605 XRX.XFRONT.XFE_O.NTAIL.n5 XRX.XFRONT.XFE_O.NTAIL.n4 5.4755
R6606 XRX.XFRONT.XFE_O.NTAIL.n7 XRX.XFRONT.XFE_O.NTAIL.n6 5.4755
R6607 XRX.XFRONT.XFE_O.NTAIL.n9 XRX.XFRONT.XFE_O.NTAIL.n8 5.4755
R6608 XRX.XFRONT.XFE_O.NTAIL.n11 XRX.XFRONT.XFE_O.NTAIL.n10 5.4755
R6609 XRX.XFRONT.XFE_O.NTAIL.n21 XRX.XFRONT.XFE_O.NTAIL.n20 5.4755
R6610 XRX.XFRONT.XFE_O.NTAIL.n19 XRX.XFRONT.XFE_O.NTAIL.n18 5.4755
R6611 XRX.XFRONT.XFE_O.NTAIL.n17 XRX.XFRONT.XFE_O.NTAIL.n16 5.4755
R6612 XRX.XFRONT.XFE_O.NTAIL.n15 XRX.XFRONT.XFE_O.NTAIL.n14 5.4755
R6613 XRX.XFRONT.XFE_O.NTAIL.n13 XRX.XFRONT.XFE_O.NTAIL.n12 5.4755
R6614 XRX.XFRONT.XFE_O.NTAIL.n28 XRX.XFRONT.XFE_O.NTAIL.n24 5.38537
R6615 XRX.XFRONT.XFE_O.NTAIL.n27 XRX.XFRONT.XFE_O.NTAIL.n26 5.38537
R6616 XRX.XFRONT.XFE_O.NTAIL.n40 XRX.XFRONT.XFE_O.NTAIL.n36 5.38537
R6617 XRX.XFRONT.XFE_O.NTAIL.n39 XRX.XFRONT.XFE_O.NTAIL.n38 5.38537
R6618 XRX.XFRONT.XFE_O.NTAIL.n34 XRX.XFRONT.XFE_O.NTAIL.n29 2.27007
R6619 XRX.XFRONT.XFE_O.NTAIL.n41 XRX.XFRONT.XFE_O.NTAIL.n34 0.86137
R6620 XRX.XFRONT.XFE_O.NTAIL.n23 XRX.XFRONT.XFE_O.NTAIL.t14 0.20525
R6621 XRX.XFRONT.XFE_O.NTAIL.n23 XRX.XFRONT.XFE_O.NTAIL.t15 0.20525
R6622 XRX.XFRONT.XFE_O.NTAIL.n24 XRX.XFRONT.XFE_O.NTAIL.t20 0.20525
R6623 XRX.XFRONT.XFE_O.NTAIL.n24 XRX.XFRONT.XFE_O.NTAIL.t13 0.20525
R6624 XRX.XFRONT.XFE_O.NTAIL.n26 XRX.XFRONT.XFE_O.NTAIL.t18 0.20525
R6625 XRX.XFRONT.XFE_O.NTAIL.n26 XRX.XFRONT.XFE_O.NTAIL.t19 0.20525
R6626 XRX.XFRONT.XFE_O.NTAIL.n25 XRX.XFRONT.XFE_O.NTAIL.t16 0.20525
R6627 XRX.XFRONT.XFE_O.NTAIL.n25 XRX.XFRONT.XFE_O.NTAIL.t17 0.20525
R6628 XRX.XFRONT.XFE_O.NTAIL.n35 XRX.XFRONT.XFE_O.NTAIL.t7 0.20525
R6629 XRX.XFRONT.XFE_O.NTAIL.n35 XRX.XFRONT.XFE_O.NTAIL.t8 0.20525
R6630 XRX.XFRONT.XFE_O.NTAIL.n36 XRX.XFRONT.XFE_O.NTAIL.t5 0.20525
R6631 XRX.XFRONT.XFE_O.NTAIL.n36 XRX.XFRONT.XFE_O.NTAIL.t6 0.20525
R6632 XRX.XFRONT.XFE_O.NTAIL.n38 XRX.XFRONT.XFE_O.NTAIL.t11 0.20525
R6633 XRX.XFRONT.XFE_O.NTAIL.n38 XRX.XFRONT.XFE_O.NTAIL.t12 0.20525
R6634 XRX.XFRONT.XFE_O.NTAIL.n37 XRX.XFRONT.XFE_O.NTAIL.t9 0.20525
R6635 XRX.XFRONT.XFE_O.NTAIL.n37 XRX.XFRONT.XFE_O.NTAIL.t10 0.20525
R6636 XRX.XFRONT.XFE_O.NTAIL.n15 XRX.XFRONT.XFE_O.NTAIL.n13 0.189974
R6637 XRX.XFRONT.XFE_O.NTAIL.n17 XRX.XFRONT.XFE_O.NTAIL.n15 0.189974
R6638 XRX.XFRONT.XFE_O.NTAIL.n19 XRX.XFRONT.XFE_O.NTAIL.n17 0.189974
R6639 XRX.XFRONT.XFE_O.NTAIL.n21 XRX.XFRONT.XFE_O.NTAIL.n19 0.189974
R6640 XRX.XFRONT.XFE_O.NTAIL.n11 XRX.XFRONT.XFE_O.NTAIL.n9 0.189974
R6641 XRX.XFRONT.XFE_O.NTAIL.n9 XRX.XFRONT.XFE_O.NTAIL.n7 0.189974
R6642 XRX.XFRONT.XFE_O.NTAIL.n7 XRX.XFRONT.XFE_O.NTAIL.n5 0.189974
R6643 XRX.XFRONT.XFE_O.NTAIL.n5 XRX.XFRONT.XFE_O.NTAIL.n3 0.189974
R6644 XRX.XFRONT.XFE_O.NTAIL.n3 XRX.XFRONT.XFE_O.NTAIL.n1 0.189974
R6645 XRX.XFRONT.XFE_O.NTAIL.n28 XRX.XFRONT.XFE_O.NTAIL.n27 0.189974
R6646 XRX.XFRONT.XFE_O.NTAIL.n40 XRX.XFRONT.XFE_O.NTAIL.n39 0.189974
R6647 XRX.XFRONT.XFE_O.NTAIL.n0 XRX.XFRONT.XFE_O.NTAIL.t42 0.1643
R6648 XRX.XFRONT.XFE_O.NTAIL.n0 XRX.XFRONT.XFE_O.NTAIL.t43 0.1643
R6649 XRX.XFRONT.XFE_O.NTAIL.n30 XRX.XFRONT.XFE_O.NTAIL.t3 0.1643
R6650 XRX.XFRONT.XFE_O.NTAIL.n30 XRX.XFRONT.XFE_O.NTAIL.t4 0.1643
R6651 XRX.XFRONT.XFE_O.NTAIL.n31 XRX.XFRONT.XFE_O.NTAIL.t1 0.1643
R6652 XRX.XFRONT.XFE_O.NTAIL.n31 XRX.XFRONT.XFE_O.NTAIL.t2 0.1643
R6653 XRX.XFRONT.XFE_O.NTAIL.n2 XRX.XFRONT.XFE_O.NTAIL.t40 0.1643
R6654 XRX.XFRONT.XFE_O.NTAIL.n2 XRX.XFRONT.XFE_O.NTAIL.t41 0.1643
R6655 XRX.XFRONT.XFE_O.NTAIL.n4 XRX.XFRONT.XFE_O.NTAIL.t38 0.1643
R6656 XRX.XFRONT.XFE_O.NTAIL.n4 XRX.XFRONT.XFE_O.NTAIL.t39 0.1643
R6657 XRX.XFRONT.XFE_O.NTAIL.n6 XRX.XFRONT.XFE_O.NTAIL.t36 0.1643
R6658 XRX.XFRONT.XFE_O.NTAIL.n6 XRX.XFRONT.XFE_O.NTAIL.t37 0.1643
R6659 XRX.XFRONT.XFE_O.NTAIL.n8 XRX.XFRONT.XFE_O.NTAIL.t34 0.1643
R6660 XRX.XFRONT.XFE_O.NTAIL.n8 XRX.XFRONT.XFE_O.NTAIL.t35 0.1643
R6661 XRX.XFRONT.XFE_O.NTAIL.n10 XRX.XFRONT.XFE_O.NTAIL.t32 0.1643
R6662 XRX.XFRONT.XFE_O.NTAIL.n10 XRX.XFRONT.XFE_O.NTAIL.t33 0.1643
R6663 XRX.XFRONT.XFE_O.NTAIL.n20 XRX.XFRONT.XFE_O.NTAIL.t30 0.1643
R6664 XRX.XFRONT.XFE_O.NTAIL.n20 XRX.XFRONT.XFE_O.NTAIL.t31 0.1643
R6665 XRX.XFRONT.XFE_O.NTAIL.n18 XRX.XFRONT.XFE_O.NTAIL.t28 0.1643
R6666 XRX.XFRONT.XFE_O.NTAIL.n18 XRX.XFRONT.XFE_O.NTAIL.t29 0.1643
R6667 XRX.XFRONT.XFE_O.NTAIL.n16 XRX.XFRONT.XFE_O.NTAIL.t26 0.1643
R6668 XRX.XFRONT.XFE_O.NTAIL.n16 XRX.XFRONT.XFE_O.NTAIL.t27 0.1643
R6669 XRX.XFRONT.XFE_O.NTAIL.n14 XRX.XFRONT.XFE_O.NTAIL.t24 0.1643
R6670 XRX.XFRONT.XFE_O.NTAIL.n14 XRX.XFRONT.XFE_O.NTAIL.t25 0.1643
R6671 XRX.XFRONT.XFE_O.NTAIL.n12 XRX.XFRONT.XFE_O.NTAIL.t22 0.1643
R6672 XRX.XFRONT.XFE_O.NTAIL.n12 XRX.XFRONT.XFE_O.NTAIL.t23 0.1643
R6673 XRX.XFRONT.XFE_O.NTAIL.n22 XRX.XFRONT.XFE_O.NTAIL.n21 0.0952368
R6674 XRX.XFRONT.XFE_O.NTAIL.n22 XRX.XFRONT.XFE_O.NTAIL.n11 0.0952368
R6675 XRX.XFRONT.XFE_O.NTAIL.n33 XRX.XFRONT.XFE_O.NTAIL.n32 0.0478684
R6676 XRX.XFRONT.XFE_O.NTAIL XRX.XFRONT.XFE_O.NTAIL.n41 0.0396304
R6677 XRX.XFRONT.XFE_E.NTAIL.n35 XRX.XFRONT.XFE_E.NTAIL.n28 13.0309
R6678 XRX.XFRONT.XFE_E.NTAIL XRX.XFRONT.XFE_E.NTAIL.n5 11.544
R6679 XRX.XFRONT.XFE_E.NTAIL.n35 XRX.XFRONT.XFE_E.NTAIL.n34 11.5048
R6680 XRX.XFRONT.XFE_E.NTAIL.n40 XRX.XFRONT.XFE_E.NTAIL.n39 9.03963
R6681 XRX.XFRONT.XFE_E.NTAIL.n7 XRX.XFRONT.XFE_E.NTAIL.t44 5.82877
R6682 XRX.XFRONT.XFE_E.NTAIL.n17 XRX.XFRONT.XFE_E.NTAIL.t21 5.82877
R6683 XRX.XFRONT.XFE_E.NTAIL.n39 XRX.XFRONT.XFE_E.NTAIL.t20 5.78141
R6684 XRX.XFRONT.XFE_E.NTAIL.n38 XRX.XFRONT.XFE_E.NTAIL.n36 5.66497
R6685 XRX.XFRONT.XFE_E.NTAIL.n2 XRX.XFRONT.XFE_E.NTAIL.n0 5.57485
R6686 XRX.XFRONT.XFE_E.NTAIL.n5 XRX.XFRONT.XFE_E.NTAIL.n4 5.57485
R6687 XRX.XFRONT.XFE_E.NTAIL.n31 XRX.XFRONT.XFE_E.NTAIL.n29 5.57485
R6688 XRX.XFRONT.XFE_E.NTAIL.n34 XRX.XFRONT.XFE_E.NTAIL.n33 5.57485
R6689 XRX.XFRONT.XFE_E.NTAIL.n7 XRX.XFRONT.XFE_E.NTAIL.n6 5.4755
R6690 XRX.XFRONT.XFE_E.NTAIL.n38 XRX.XFRONT.XFE_E.NTAIL.n37 5.4755
R6691 XRX.XFRONT.XFE_E.NTAIL.n9 XRX.XFRONT.XFE_E.NTAIL.n8 5.4755
R6692 XRX.XFRONT.XFE_E.NTAIL.n11 XRX.XFRONT.XFE_E.NTAIL.n10 5.4755
R6693 XRX.XFRONT.XFE_E.NTAIL.n13 XRX.XFRONT.XFE_E.NTAIL.n12 5.4755
R6694 XRX.XFRONT.XFE_E.NTAIL.n15 XRX.XFRONT.XFE_E.NTAIL.n14 5.4755
R6695 XRX.XFRONT.XFE_E.NTAIL.n27 XRX.XFRONT.XFE_E.NTAIL.n26 5.4755
R6696 XRX.XFRONT.XFE_E.NTAIL.n25 XRX.XFRONT.XFE_E.NTAIL.n24 5.4755
R6697 XRX.XFRONT.XFE_E.NTAIL.n23 XRX.XFRONT.XFE_E.NTAIL.n22 5.4755
R6698 XRX.XFRONT.XFE_E.NTAIL.n21 XRX.XFRONT.XFE_E.NTAIL.n20 5.4755
R6699 XRX.XFRONT.XFE_E.NTAIL.n19 XRX.XFRONT.XFE_E.NTAIL.n18 5.4755
R6700 XRX.XFRONT.XFE_E.NTAIL.n17 XRX.XFRONT.XFE_E.NTAIL.n16 5.4755
R6701 XRX.XFRONT.XFE_E.NTAIL.n2 XRX.XFRONT.XFE_E.NTAIL.n1 5.38537
R6702 XRX.XFRONT.XFE_E.NTAIL.n5 XRX.XFRONT.XFE_E.NTAIL.n3 5.38537
R6703 XRX.XFRONT.XFE_E.NTAIL.n31 XRX.XFRONT.XFE_E.NTAIL.n30 5.38537
R6704 XRX.XFRONT.XFE_E.NTAIL.n34 XRX.XFRONT.XFE_E.NTAIL.n32 5.38537
R6705 XRX.XFRONT.XFE_E.NTAIL.n40 XRX.XFRONT.XFE_E.NTAIL.n35 2.27007
R6706 XRX.XFRONT.XFE_E.NTAIL XRX.XFRONT.XFE_E.NTAIL.n40 0.822239
R6707 XRX.XFRONT.XFE_E.NTAIL.n0 XRX.XFRONT.XFE_E.NTAIL.t3 0.20525
R6708 XRX.XFRONT.XFE_E.NTAIL.n0 XRX.XFRONT.XFE_E.NTAIL.t4 0.20525
R6709 XRX.XFRONT.XFE_E.NTAIL.n1 XRX.XFRONT.XFE_E.NTAIL.t5 0.20525
R6710 XRX.XFRONT.XFE_E.NTAIL.n1 XRX.XFRONT.XFE_E.NTAIL.t6 0.20525
R6711 XRX.XFRONT.XFE_E.NTAIL.n3 XRX.XFRONT.XFE_E.NTAIL.t1 0.20525
R6712 XRX.XFRONT.XFE_E.NTAIL.n3 XRX.XFRONT.XFE_E.NTAIL.t0 0.20525
R6713 XRX.XFRONT.XFE_E.NTAIL.n4 XRX.XFRONT.XFE_E.NTAIL.t7 0.20525
R6714 XRX.XFRONT.XFE_E.NTAIL.n4 XRX.XFRONT.XFE_E.NTAIL.t2 0.20525
R6715 XRX.XFRONT.XFE_E.NTAIL.n29 XRX.XFRONT.XFE_E.NTAIL.t13 0.20525
R6716 XRX.XFRONT.XFE_E.NTAIL.n29 XRX.XFRONT.XFE_E.NTAIL.t9 0.20525
R6717 XRX.XFRONT.XFE_E.NTAIL.n30 XRX.XFRONT.XFE_E.NTAIL.t11 0.20525
R6718 XRX.XFRONT.XFE_E.NTAIL.n30 XRX.XFRONT.XFE_E.NTAIL.t12 0.20525
R6719 XRX.XFRONT.XFE_E.NTAIL.n32 XRX.XFRONT.XFE_E.NTAIL.t15 0.20525
R6720 XRX.XFRONT.XFE_E.NTAIL.n32 XRX.XFRONT.XFE_E.NTAIL.t10 0.20525
R6721 XRX.XFRONT.XFE_E.NTAIL.n33 XRX.XFRONT.XFE_E.NTAIL.t8 0.20525
R6722 XRX.XFRONT.XFE_E.NTAIL.n33 XRX.XFRONT.XFE_E.NTAIL.t14 0.20525
R6723 XRX.XFRONT.XFE_E.NTAIL.n19 XRX.XFRONT.XFE_E.NTAIL.n17 0.189974
R6724 XRX.XFRONT.XFE_E.NTAIL.n21 XRX.XFRONT.XFE_E.NTAIL.n19 0.189974
R6725 XRX.XFRONT.XFE_E.NTAIL.n23 XRX.XFRONT.XFE_E.NTAIL.n21 0.189974
R6726 XRX.XFRONT.XFE_E.NTAIL.n25 XRX.XFRONT.XFE_E.NTAIL.n23 0.189974
R6727 XRX.XFRONT.XFE_E.NTAIL.n27 XRX.XFRONT.XFE_E.NTAIL.n25 0.189974
R6728 XRX.XFRONT.XFE_E.NTAIL.n15 XRX.XFRONT.XFE_E.NTAIL.n13 0.189974
R6729 XRX.XFRONT.XFE_E.NTAIL.n13 XRX.XFRONT.XFE_E.NTAIL.n11 0.189974
R6730 XRX.XFRONT.XFE_E.NTAIL.n11 XRX.XFRONT.XFE_E.NTAIL.n9 0.189974
R6731 XRX.XFRONT.XFE_E.NTAIL.n9 XRX.XFRONT.XFE_E.NTAIL.n7 0.189974
R6732 XRX.XFRONT.XFE_E.NTAIL.n5 XRX.XFRONT.XFE_E.NTAIL.n2 0.189974
R6733 XRX.XFRONT.XFE_E.NTAIL.n34 XRX.XFRONT.XFE_E.NTAIL.n31 0.189974
R6734 XRX.XFRONT.XFE_E.NTAIL.n6 XRX.XFRONT.XFE_E.NTAIL.t42 0.1643
R6735 XRX.XFRONT.XFE_E.NTAIL.n6 XRX.XFRONT.XFE_E.NTAIL.t43 0.1643
R6736 XRX.XFRONT.XFE_E.NTAIL.n37 XRX.XFRONT.XFE_E.NTAIL.t18 0.1643
R6737 XRX.XFRONT.XFE_E.NTAIL.n37 XRX.XFRONT.XFE_E.NTAIL.t19 0.1643
R6738 XRX.XFRONT.XFE_E.NTAIL.n36 XRX.XFRONT.XFE_E.NTAIL.t16 0.1643
R6739 XRX.XFRONT.XFE_E.NTAIL.n36 XRX.XFRONT.XFE_E.NTAIL.t17 0.1643
R6740 XRX.XFRONT.XFE_E.NTAIL.n8 XRX.XFRONT.XFE_E.NTAIL.t40 0.1643
R6741 XRX.XFRONT.XFE_E.NTAIL.n8 XRX.XFRONT.XFE_E.NTAIL.t41 0.1643
R6742 XRX.XFRONT.XFE_E.NTAIL.n10 XRX.XFRONT.XFE_E.NTAIL.t38 0.1643
R6743 XRX.XFRONT.XFE_E.NTAIL.n10 XRX.XFRONT.XFE_E.NTAIL.t39 0.1643
R6744 XRX.XFRONT.XFE_E.NTAIL.n12 XRX.XFRONT.XFE_E.NTAIL.t36 0.1643
R6745 XRX.XFRONT.XFE_E.NTAIL.n12 XRX.XFRONT.XFE_E.NTAIL.t37 0.1643
R6746 XRX.XFRONT.XFE_E.NTAIL.n14 XRX.XFRONT.XFE_E.NTAIL.t34 0.1643
R6747 XRX.XFRONT.XFE_E.NTAIL.n14 XRX.XFRONT.XFE_E.NTAIL.t35 0.1643
R6748 XRX.XFRONT.XFE_E.NTAIL.n26 XRX.XFRONT.XFE_E.NTAIL.t32 0.1643
R6749 XRX.XFRONT.XFE_E.NTAIL.n26 XRX.XFRONT.XFE_E.NTAIL.t33 0.1643
R6750 XRX.XFRONT.XFE_E.NTAIL.n24 XRX.XFRONT.XFE_E.NTAIL.t30 0.1643
R6751 XRX.XFRONT.XFE_E.NTAIL.n24 XRX.XFRONT.XFE_E.NTAIL.t31 0.1643
R6752 XRX.XFRONT.XFE_E.NTAIL.n22 XRX.XFRONT.XFE_E.NTAIL.t28 0.1643
R6753 XRX.XFRONT.XFE_E.NTAIL.n22 XRX.XFRONT.XFE_E.NTAIL.t29 0.1643
R6754 XRX.XFRONT.XFE_E.NTAIL.n20 XRX.XFRONT.XFE_E.NTAIL.t26 0.1643
R6755 XRX.XFRONT.XFE_E.NTAIL.n20 XRX.XFRONT.XFE_E.NTAIL.t27 0.1643
R6756 XRX.XFRONT.XFE_E.NTAIL.n18 XRX.XFRONT.XFE_E.NTAIL.t24 0.1643
R6757 XRX.XFRONT.XFE_E.NTAIL.n18 XRX.XFRONT.XFE_E.NTAIL.t25 0.1643
R6758 XRX.XFRONT.XFE_E.NTAIL.n16 XRX.XFRONT.XFE_E.NTAIL.t22 0.1643
R6759 XRX.XFRONT.XFE_E.NTAIL.n16 XRX.XFRONT.XFE_E.NTAIL.t23 0.1643
R6760 XRX.XFRONT.XFE_E.NTAIL.n28 XRX.XFRONT.XFE_E.NTAIL.n27 0.0952368
R6761 XRX.XFRONT.XFE_E.NTAIL.n28 XRX.XFRONT.XFE_E.NTAIL.n15 0.0952368
R6762 XRX.XFRONT.XFE_E.NTAIL.n39 XRX.XFRONT.XFE_E.NTAIL.n38 0.0478684
R6763 XRX.XFRONT.XFE_O.DN.t13 XRX.XFRONT.XFE_O.DN.n10 127.788
R6764 XRX.XFRONT.XFE_O.DN.t6 XRX.XFRONT.XFE_O.DN.n0 127.776
R6765 XRX.XFRONT.XFE_O.DN.n10 XRX.XFRONT.XFE_O.DN.t12 127.668
R6766 XRX.XFRONT.XFE_O.DN.n9 XRX.XFRONT.XFE_O.DN.t11 127.668
R6767 XRX.XFRONT.XFE_O.DN.n8 XRX.XFRONT.XFE_O.DN.t10 127.668
R6768 XRX.XFRONT.XFE_O.DN.n7 XRX.XFRONT.XFE_O.DN.t9 127.668
R6769 XRX.XFRONT.XFE_O.DN.n6 XRX.XFRONT.XFE_O.DN.t8 127.668
R6770 XRX.XFRONT.XFE_O.DN.t7 XRX.XFRONT.XFE_O.DN.n0 127.668
R6771 XRX.XFRONT.XFE_O.DN.n11 XRX.XFRONT.XFE_O.DN.t13 113.632
R6772 XRX.XFRONT.XFE_O.DN.n1 XRX.XFRONT.XFE_O.DN.t6 113.629
R6773 XRX.XFRONT.XFE_O.DN.t12 XRX.XFRONT.XFE_O.DN.n5 109.174
R6774 XRX.XFRONT.XFE_O.DN.n13 XRX.XFRONT.XFE_O.DN.t11 109.174
R6775 XRX.XFRONT.XFE_O.DN.n14 XRX.XFRONT.XFE_O.DN.t10 109.174
R6776 XRX.XFRONT.XFE_O.DN.n15 XRX.XFRONT.XFE_O.DN.t9 109.174
R6777 XRX.XFRONT.XFE_O.DN.n16 XRX.XFRONT.XFE_O.DN.t8 109.174
R6778 XRX.XFRONT.XFE_O.DN.n3 XRX.XFRONT.XFE_O.DN.t7 109.174
R6779 XRX.XFRONT.XFE_O.DN.n13 XRX.XFRONT.XFE_O.DN.n12 18.4942
R6780 XRX.XFRONT.XFE_O.DN.n14 XRX.XFRONT.XFE_O.DN.n4 18.4942
R6781 XRX.XFRONT.XFE_O.DN.n15 XRX.XFRONT.XFE_O.DN.n2 18.4942
R6782 XRX.XFRONT.XFE_O.DN.n17 XRX.XFRONT.XFE_O.DN.n16 18.4942
R6783 XRX.XFRONT.XFE_O.DN.n23 XRX.XFRONT.XFE_O.DN.n22 14.1606
R6784 XRX.XFRONT.XFE_O.DN.n14 XRX.XFRONT.XFE_O.DN.n13 11.6805
R6785 XRX.XFRONT.XFE_O.DN.n13 XRX.XFRONT.XFE_O.DN.n5 11.6805
R6786 XRX.XFRONT.XFE_O.DN.n15 XRX.XFRONT.XFE_O.DN.n14 11.6805
R6787 XRX.XFRONT.XFE_O.DN.n16 XRX.XFRONT.XFE_O.DN.n15 11.6805
R6788 XRX.XFRONT.XFE_O.DN.n16 XRX.XFRONT.XFE_O.DN.n3 11.6805
R6789 XRX.XFRONT.XFE_O.DN.n19 XRX.XFRONT.XFE_O.DN.n0 10.8201
R6790 XRX.XFRONT.XFE_O.DN.n25 XRX.XFRONT.XFE_O.DN.n24 10.5266
R6791 XRX.XFRONT.XFE_O.DN.n19 XRX.XFRONT.XFE_O.DN.n18 9.02007
R6792 XRX.XFRONT.XFE_O.DN.n23 XRX.XFRONT.XFE_O.DN.n19 7.2005
R6793 XRX.XFRONT.XFE_O.DN.n12 XRX.XFRONT.XFE_O.DN.n11 7.17687
R6794 XRX.XFRONT.XFE_O.DN.n18 XRX.XFRONT.XFE_O.DN.n1 7.05405
R6795 XRX.XFRONT.XFE_O.DN.n24 XRX.XFRONT.XFE_O.DN.t3 5.7796
R6796 XRX.XFRONT.XFE_O.DN.n21 XRX.XFRONT.XFE_O.DN.t2 5.73764
R6797 XRX.XFRONT.XFE_O.DN.n24 XRX.XFRONT.XFE_O.DN.t4 5.59012
R6798 XRX.XFRONT.XFE_O.DN.n22 XRX.XFRONT.XFE_O.DN.t5 5.54817
R6799 XRX.XFRONT.XFE_O.DN.n21 XRX.XFRONT.XFE_O.DN.n20 5.32067
R6800 XRX.XFRONT.XFE_O.DN.n3 XRX.XFRONT.XFE_O.DN.n1 4.4296
R6801 XRX.XFRONT.XFE_O.DN.n11 XRX.XFRONT.XFE_O.DN.n5 4.42851
R6802 XRX.XFRONT.XFE_O.DN.n25 XRX.XFRONT.XFE_O.DN.n23 0.978761
R6803 XRX.XFRONT.XFE_O.DN.n20 XRX.XFRONT.XFE_O.DN.t1 0.228
R6804 XRX.XFRONT.XFE_O.DN.n20 XRX.XFRONT.XFE_O.DN.t0 0.228
R6805 XRX.XFRONT.XFE_O.DN.n22 XRX.XFRONT.XFE_O.DN.n21 0.189974
R6806 XRX.XFRONT.XFE_O.DN.n10 XRX.XFRONT.XFE_O.DN.n9 0.1205
R6807 XRX.XFRONT.XFE_O.DN.n9 XRX.XFRONT.XFE_O.DN.n8 0.1205
R6808 XRX.XFRONT.XFE_O.DN.n8 XRX.XFRONT.XFE_O.DN.n7 0.1205
R6809 XRX.XFRONT.XFE_O.DN.n7 XRX.XFRONT.XFE_O.DN.n6 0.1205
R6810 XRX.XFRONT.XFE_O.DN.n12 XRX.XFRONT.XFE_O.DN.n4 0.1205
R6811 XRX.XFRONT.XFE_O.DN.n4 XRX.XFRONT.XFE_O.DN.n2 0.1205
R6812 XRX.XFRONT.XFE_O.DN.n17 XRX.XFRONT.XFE_O.DN.n2 0.1205
R6813 XRX.XFRONT.XFE_O.DN.n6 XRX.XFRONT.XFE_O.DN.n0 0.1085
R6814 XRX.XFRONT.XFE_O.DN.n18 XRX.XFRONT.XFE_O.DN.n17 0.1085
R6815 XRX.XFRONT.XFE_O.DN XRX.XFRONT.XFE_O.DN.n25 0.0396304
R6816 XRX.XFRONT.XFE_O.DP.t13 XRX.XFRONT.XFE_O.DP.n15 127.788
R6817 XRX.XFRONT.XFE_O.DP.t6 XRX.XFRONT.XFE_O.DP.n5 127.776
R6818 XRX.XFRONT.XFE_O.DP.n15 XRX.XFRONT.XFE_O.DP.t12 127.668
R6819 XRX.XFRONT.XFE_O.DP.n14 XRX.XFRONT.XFE_O.DP.t11 127.668
R6820 XRX.XFRONT.XFE_O.DP.n13 XRX.XFRONT.XFE_O.DP.t10 127.668
R6821 XRX.XFRONT.XFE_O.DP.n12 XRX.XFRONT.XFE_O.DP.t9 127.668
R6822 XRX.XFRONT.XFE_O.DP.n11 XRX.XFRONT.XFE_O.DP.t8 127.668
R6823 XRX.XFRONT.XFE_O.DP.t7 XRX.XFRONT.XFE_O.DP.n5 127.668
R6824 XRX.XFRONT.XFE_O.DP.n16 XRX.XFRONT.XFE_O.DP.t13 113.632
R6825 XRX.XFRONT.XFE_O.DP.n6 XRX.XFRONT.XFE_O.DP.t6 113.629
R6826 XRX.XFRONT.XFE_O.DP.t12 XRX.XFRONT.XFE_O.DP.n10 109.174
R6827 XRX.XFRONT.XFE_O.DP.n18 XRX.XFRONT.XFE_O.DP.t11 109.174
R6828 XRX.XFRONT.XFE_O.DP.n19 XRX.XFRONT.XFE_O.DP.t10 109.174
R6829 XRX.XFRONT.XFE_O.DP.n20 XRX.XFRONT.XFE_O.DP.t9 109.174
R6830 XRX.XFRONT.XFE_O.DP.n21 XRX.XFRONT.XFE_O.DP.t8 109.174
R6831 XRX.XFRONT.XFE_O.DP.n8 XRX.XFRONT.XFE_O.DP.t7 109.174
R6832 XRX.XFRONT.XFE_O.DP.n18 XRX.XFRONT.XFE_O.DP.n17 18.4942
R6833 XRX.XFRONT.XFE_O.DP.n19 XRX.XFRONT.XFE_O.DP.n9 18.4942
R6834 XRX.XFRONT.XFE_O.DP.n20 XRX.XFRONT.XFE_O.DP.n7 18.4942
R6835 XRX.XFRONT.XFE_O.DP.n22 XRX.XFRONT.XFE_O.DP.n21 18.4942
R6836 XRX.XFRONT.XFE_O.DP.n4 XRX.XFRONT.XFE_O.DP.n3 14.5055
R6837 XRX.XFRONT.XFE_O.DP.n4 XRX.XFRONT.XFE_O.DP.n0 11.7788
R6838 XRX.XFRONT.XFE_O.DP.n19 XRX.XFRONT.XFE_O.DP.n18 11.6805
R6839 XRX.XFRONT.XFE_O.DP.n18 XRX.XFRONT.XFE_O.DP.n10 11.6805
R6840 XRX.XFRONT.XFE_O.DP.n20 XRX.XFRONT.XFE_O.DP.n19 11.6805
R6841 XRX.XFRONT.XFE_O.DP.n21 XRX.XFRONT.XFE_O.DP.n20 11.6805
R6842 XRX.XFRONT.XFE_O.DP.n21 XRX.XFRONT.XFE_O.DP.n8 11.6805
R6843 XRX.XFRONT.XFE_O.DP.n24 XRX.XFRONT.XFE_O.DP.n5 10.8396
R6844 XRX.XFRONT.XFE_O.DP.n24 XRX.XFRONT.XFE_O.DP.n23 9.0005
R6845 XRX.XFRONT.XFE_O.DP.n17 XRX.XFRONT.XFE_O.DP.n16 7.17687
R6846 XRX.XFRONT.XFE_O.DP.n23 XRX.XFRONT.XFE_O.DP.n6 7.05405
R6847 XRX.XFRONT.XFE_O.DP.n2 XRX.XFRONT.XFE_O.DP.t2 5.73764
R6848 XRX.XFRONT.XFE_O.DP.n0 XRX.XFRONT.XFE_O.DP.t1 5.70855
R6849 XRX.XFRONT.XFE_O.DP.n0 XRX.XFRONT.XFE_O.DP.t0 5.66118
R6850 XRX.XFRONT.XFE_O.DP.n3 XRX.XFRONT.XFE_O.DP.t5 5.54817
R6851 XRX.XFRONT.XFE_O.DP.n2 XRX.XFRONT.XFE_O.DP.n1 5.32067
R6852 XRX.XFRONT.XFE_O.DP.n25 XRX.XFRONT.XFE_O.DP.n24 4.75485
R6853 XRX.XFRONT.XFE_O.DP.n8 XRX.XFRONT.XFE_O.DP.n6 4.4296
R6854 XRX.XFRONT.XFE_O.DP.n16 XRX.XFRONT.XFE_O.DP.n10 4.42851
R6855 XRX.XFRONT.XFE_O.DP.n25 XRX.XFRONT.XFE_O.DP.n4 1.8005
R6856 XRX.XFRONT.XFE_O.DP.n1 XRX.XFRONT.XFE_O.DP.t4 0.228
R6857 XRX.XFRONT.XFE_O.DP.n1 XRX.XFRONT.XFE_O.DP.t3 0.228
R6858 XRX.XFRONT.XFE_O.DP.n3 XRX.XFRONT.XFE_O.DP.n2 0.189974
R6859 XRX.XFRONT.XFE_O.DP.n15 XRX.XFRONT.XFE_O.DP.n14 0.1205
R6860 XRX.XFRONT.XFE_O.DP.n14 XRX.XFRONT.XFE_O.DP.n13 0.1205
R6861 XRX.XFRONT.XFE_O.DP.n13 XRX.XFRONT.XFE_O.DP.n12 0.1205
R6862 XRX.XFRONT.XFE_O.DP.n12 XRX.XFRONT.XFE_O.DP.n11 0.1205
R6863 XRX.XFRONT.XFE_O.DP.n17 XRX.XFRONT.XFE_O.DP.n9 0.1205
R6864 XRX.XFRONT.XFE_O.DP.n9 XRX.XFRONT.XFE_O.DP.n7 0.1205
R6865 XRX.XFRONT.XFE_O.DP.n22 XRX.XFRONT.XFE_O.DP.n7 0.1205
R6866 XRX.XFRONT.XFE_O.DP.n11 XRX.XFRONT.XFE_O.DP.n5 0.1085
R6867 XRX.XFRONT.XFE_O.DP.n23 XRX.XFRONT.XFE_O.DP.n22 0.1085
R6868 XRX.XFRONT.XFE_O.DP XRX.XFRONT.XFE_O.DP.n25 0.0396304
R6869 XRX.XFRONT.XFE_E.DP.t6 XRX.XFRONT.XFE_E.DP.n7 127.788
R6870 XRX.XFRONT.XFE_E.DP.t13 XRX.XFRONT.XFE_E.DP.n0 127.776
R6871 XRX.XFRONT.XFE_E.DP.t11 XRX.XFRONT.XFE_E.DP.n14 127.668
R6872 XRX.XFRONT.XFE_E.DP.t12 XRX.XFRONT.XFE_E.DP.n0 127.668
R6873 XRX.XFRONT.XFE_E.DP.n7 XRX.XFRONT.XFE_E.DP.t7 127.668
R6874 XRX.XFRONT.XFE_E.DP.t8 XRX.XFRONT.XFE_E.DP.n3 127.668
R6875 XRX.XFRONT.XFE_E.DP.n12 XRX.XFRONT.XFE_E.DP.t9 127.668
R6876 XRX.XFRONT.XFE_E.DP.n13 XRX.XFRONT.XFE_E.DP.t10 127.668
R6877 XRX.XFRONT.XFE_E.DP.n8 XRX.XFRONT.XFE_E.DP.t6 113.632
R6878 XRX.XFRONT.XFE_E.DP.n17 XRX.XFRONT.XFE_E.DP.t13 113.629
R6879 XRX.XFRONT.XFE_E.DP.n15 XRX.XFRONT.XFE_E.DP.t11 109.174
R6880 XRX.XFRONT.XFE_E.DP.n16 XRX.XFRONT.XFE_E.DP.t12 109.174
R6881 XRX.XFRONT.XFE_E.DP.n9 XRX.XFRONT.XFE_E.DP.t7 109.174
R6882 XRX.XFRONT.XFE_E.DP.n10 XRX.XFRONT.XFE_E.DP.t8 109.174
R6883 XRX.XFRONT.XFE_E.DP.t9 XRX.XFRONT.XFE_E.DP.n11 109.174
R6884 XRX.XFRONT.XFE_E.DP.t10 XRX.XFRONT.XFE_E.DP.n2 109.174
R6885 XRX.XFRONT.XFE_E.DP.n15 XRX.XFRONT.XFE_E.DP.n1 18.4942
R6886 XRX.XFRONT.XFE_E.DP.n10 XRX.XFRONT.XFE_E.DP.n6 18.4942
R6887 XRX.XFRONT.XFE_E.DP.n11 XRX.XFRONT.XFE_E.DP.n5 18.4942
R6888 XRX.XFRONT.XFE_E.DP.n4 XRX.XFRONT.XFE_E.DP.n2 18.4942
R6889 XRX.XFRONT.XFE_E.DP.n24 XRX.XFRONT.XFE_E.DP.n23 14.5055
R6890 XRX.XFRONT.XFE_E.DP.n24 XRX.XFRONT.XFE_E.DP.n20 11.7788
R6891 XRX.XFRONT.XFE_E.DP.n16 XRX.XFRONT.XFE_E.DP.n15 11.6805
R6892 XRX.XFRONT.XFE_E.DP.n10 XRX.XFRONT.XFE_E.DP.n9 11.6805
R6893 XRX.XFRONT.XFE_E.DP.n11 XRX.XFRONT.XFE_E.DP.n10 11.6805
R6894 XRX.XFRONT.XFE_E.DP.n11 XRX.XFRONT.XFE_E.DP.n2 11.6805
R6895 XRX.XFRONT.XFE_E.DP.n15 XRX.XFRONT.XFE_E.DP.n2 11.6805
R6896 XRX.XFRONT.XFE_E.DP.n19 XRX.XFRONT.XFE_E.DP.n0 10.8396
R6897 XRX.XFRONT.XFE_E.DP.n19 XRX.XFRONT.XFE_E.DP.n18 9.0005
R6898 XRX.XFRONT.XFE_E.DP.n8 XRX.XFRONT.XFE_E.DP.n6 7.17687
R6899 XRX.XFRONT.XFE_E.DP.n18 XRX.XFRONT.XFE_E.DP.n17 7.05405
R6900 XRX.XFRONT.XFE_E.DP.n22 XRX.XFRONT.XFE_E.DP.t1 5.73764
R6901 XRX.XFRONT.XFE_E.DP.n20 XRX.XFRONT.XFE_E.DP.t2 5.70855
R6902 XRX.XFRONT.XFE_E.DP.n20 XRX.XFRONT.XFE_E.DP.t3 5.66118
R6903 XRX.XFRONT.XFE_E.DP.n23 XRX.XFRONT.XFE_E.DP.t4 5.54817
R6904 XRX.XFRONT.XFE_E.DP.n22 XRX.XFRONT.XFE_E.DP.n21 5.32067
R6905 XRX.XFRONT.XFE_E.DP XRX.XFRONT.XFE_E.DP.n19 4.79398
R6906 XRX.XFRONT.XFE_E.DP.n17 XRX.XFRONT.XFE_E.DP.n16 4.4296
R6907 XRX.XFRONT.XFE_E.DP.n9 XRX.XFRONT.XFE_E.DP.n8 4.42851
R6908 XRX.XFRONT.XFE_E.DP XRX.XFRONT.XFE_E.DP.n24 1.76137
R6909 XRX.XFRONT.XFE_E.DP.n21 XRX.XFRONT.XFE_E.DP.t0 0.228
R6910 XRX.XFRONT.XFE_E.DP.n21 XRX.XFRONT.XFE_E.DP.t5 0.228
R6911 XRX.XFRONT.XFE_E.DP.n23 XRX.XFRONT.XFE_E.DP.n22 0.189974
R6912 XRX.XFRONT.XFE_E.DP.n4 XRX.XFRONT.XFE_E.DP.n1 0.1205
R6913 XRX.XFRONT.XFE_E.DP.n5 XRX.XFRONT.XFE_E.DP.n4 0.1205
R6914 XRX.XFRONT.XFE_E.DP.n6 XRX.XFRONT.XFE_E.DP.n5 0.1205
R6915 XRX.XFRONT.XFE_E.DP.n14 XRX.XFRONT.XFE_E.DP.n13 0.1205
R6916 XRX.XFRONT.XFE_E.DP.n13 XRX.XFRONT.XFE_E.DP.n12 0.1205
R6917 XRX.XFRONT.XFE_E.DP.n12 XRX.XFRONT.XFE_E.DP.n3 0.1205
R6918 XRX.XFRONT.XFE_E.DP.n7 XRX.XFRONT.XFE_E.DP.n3 0.1205
R6919 XRX.XFRONT.XFE_E.DP.n18 XRX.XFRONT.XFE_E.DP.n1 0.1085
R6920 XRX.XFRONT.XFE_E.DP.n14 XRX.XFRONT.XFE_E.DP.n0 0.1085
R6921 XRX.XFRONT.XFE_E.DN.t6 XRX.XFRONT.XFE_E.DN.n8 127.788
R6922 XRX.XFRONT.XFE_E.DN.t13 XRX.XFRONT.XFE_E.DN.n1 127.776
R6923 XRX.XFRONT.XFE_E.DN.t11 XRX.XFRONT.XFE_E.DN.n15 127.668
R6924 XRX.XFRONT.XFE_E.DN.t12 XRX.XFRONT.XFE_E.DN.n1 127.668
R6925 XRX.XFRONT.XFE_E.DN.n8 XRX.XFRONT.XFE_E.DN.t7 127.668
R6926 XRX.XFRONT.XFE_E.DN.t8 XRX.XFRONT.XFE_E.DN.n4 127.668
R6927 XRX.XFRONT.XFE_E.DN.n13 XRX.XFRONT.XFE_E.DN.t9 127.668
R6928 XRX.XFRONT.XFE_E.DN.n14 XRX.XFRONT.XFE_E.DN.t10 127.668
R6929 XRX.XFRONT.XFE_E.DN.n9 XRX.XFRONT.XFE_E.DN.t6 113.632
R6930 XRX.XFRONT.XFE_E.DN.n18 XRX.XFRONT.XFE_E.DN.t13 113.629
R6931 XRX.XFRONT.XFE_E.DN.n16 XRX.XFRONT.XFE_E.DN.t11 109.174
R6932 XRX.XFRONT.XFE_E.DN.n17 XRX.XFRONT.XFE_E.DN.t12 109.174
R6933 XRX.XFRONT.XFE_E.DN.n10 XRX.XFRONT.XFE_E.DN.t7 109.174
R6934 XRX.XFRONT.XFE_E.DN.n11 XRX.XFRONT.XFE_E.DN.t8 109.174
R6935 XRX.XFRONT.XFE_E.DN.t9 XRX.XFRONT.XFE_E.DN.n12 109.174
R6936 XRX.XFRONT.XFE_E.DN.t10 XRX.XFRONT.XFE_E.DN.n3 109.174
R6937 XRX.XFRONT.XFE_E.DN.n16 XRX.XFRONT.XFE_E.DN.n2 18.4942
R6938 XRX.XFRONT.XFE_E.DN.n11 XRX.XFRONT.XFE_E.DN.n7 18.4942
R6939 XRX.XFRONT.XFE_E.DN.n12 XRX.XFRONT.XFE_E.DN.n6 18.4942
R6940 XRX.XFRONT.XFE_E.DN.n5 XRX.XFRONT.XFE_E.DN.n3 18.4942
R6941 XRX.XFRONT.XFE_E.DN.n24 XRX.XFRONT.XFE_E.DN.n23 14.1606
R6942 XRX.XFRONT.XFE_E.DN.n17 XRX.XFRONT.XFE_E.DN.n16 11.6805
R6943 XRX.XFRONT.XFE_E.DN.n11 XRX.XFRONT.XFE_E.DN.n10 11.6805
R6944 XRX.XFRONT.XFE_E.DN.n12 XRX.XFRONT.XFE_E.DN.n11 11.6805
R6945 XRX.XFRONT.XFE_E.DN.n12 XRX.XFRONT.XFE_E.DN.n3 11.6805
R6946 XRX.XFRONT.XFE_E.DN.n16 XRX.XFRONT.XFE_E.DN.n3 11.6805
R6947 XRX.XFRONT.XFE_E.DN.n20 XRX.XFRONT.XFE_E.DN.n1 10.8201
R6948 XRX.XFRONT.XFE_E.DN XRX.XFRONT.XFE_E.DN.n0 10.5657
R6949 XRX.XFRONT.XFE_E.DN.n20 XRX.XFRONT.XFE_E.DN.n19 9.02007
R6950 XRX.XFRONT.XFE_E.DN.n24 XRX.XFRONT.XFE_E.DN.n20 7.2005
R6951 XRX.XFRONT.XFE_E.DN.n9 XRX.XFRONT.XFE_E.DN.n7 7.17687
R6952 XRX.XFRONT.XFE_E.DN.n19 XRX.XFRONT.XFE_E.DN.n18 7.05405
R6953 XRX.XFRONT.XFE_E.DN.n0 XRX.XFRONT.XFE_E.DN.t3 5.7796
R6954 XRX.XFRONT.XFE_E.DN.n22 XRX.XFRONT.XFE_E.DN.t4 5.73764
R6955 XRX.XFRONT.XFE_E.DN.n0 XRX.XFRONT.XFE_E.DN.t2 5.59012
R6956 XRX.XFRONT.XFE_E.DN.n23 XRX.XFRONT.XFE_E.DN.t1 5.54817
R6957 XRX.XFRONT.XFE_E.DN.n22 XRX.XFRONT.XFE_E.DN.n21 5.32067
R6958 XRX.XFRONT.XFE_E.DN.n18 XRX.XFRONT.XFE_E.DN.n17 4.4296
R6959 XRX.XFRONT.XFE_E.DN.n10 XRX.XFRONT.XFE_E.DN.n9 4.42851
R6960 XRX.XFRONT.XFE_E.DN XRX.XFRONT.XFE_E.DN.n24 0.93963
R6961 XRX.XFRONT.XFE_E.DN.n21 XRX.XFRONT.XFE_E.DN.t0 0.228
R6962 XRX.XFRONT.XFE_E.DN.n21 XRX.XFRONT.XFE_E.DN.t5 0.228
R6963 XRX.XFRONT.XFE_E.DN.n23 XRX.XFRONT.XFE_E.DN.n22 0.189974
R6964 XRX.XFRONT.XFE_E.DN.n5 XRX.XFRONT.XFE_E.DN.n2 0.1205
R6965 XRX.XFRONT.XFE_E.DN.n6 XRX.XFRONT.XFE_E.DN.n5 0.1205
R6966 XRX.XFRONT.XFE_E.DN.n7 XRX.XFRONT.XFE_E.DN.n6 0.1205
R6967 XRX.XFRONT.XFE_E.DN.n15 XRX.XFRONT.XFE_E.DN.n14 0.1205
R6968 XRX.XFRONT.XFE_E.DN.n14 XRX.XFRONT.XFE_E.DN.n13 0.1205
R6969 XRX.XFRONT.XFE_E.DN.n13 XRX.XFRONT.XFE_E.DN.n4 0.1205
R6970 XRX.XFRONT.XFE_E.DN.n8 XRX.XFRONT.XFE_E.DN.n4 0.1205
R6971 XRX.XFRONT.XFE_E.DN.n19 XRX.XFRONT.XFE_E.DN.n2 0.1085
R6972 XRX.XFRONT.XFE_E.DN.n15 XRX.XFRONT.XFE_E.DN.n1 0.1085
R6973 XRX.XFRONT.XFE_O.NIN.n13 XRX.XFRONT.XFE_O.NIN.n12 19.957
R6974 XRX.XFRONT.XFE_O.NIN.n13 XRX.XFRONT.XFE_O.NIN.n9 12.3657
R6975 XRX.XFRONT.XFE_O.NIN.n21 XRX.XFRONT.XFE_O.NIN.n20 11.9353
R6976 XRX.XFRONT.XFE_O.NIN.n15 XRX.XFRONT.XFE_O.NIN.t23 5.7796
R6977 XRX.XFRONT.XFE_O.NIN.n19 XRX.XFRONT.XFE_O.NIN.t16 5.7796
R6978 XRX.XFRONT.XFE_O.NIN.n11 XRX.XFRONT.XFE_O.NIN.t15 5.73764
R6979 XRX.XFRONT.XFE_O.NIN.n12 XRX.XFRONT.XFE_O.NIN.t12 5.6429
R6980 XRX.XFRONT.XFE_O.NIN.n2 XRX.XFRONT.XFE_O.NIN.n0 5.57485
R6981 XRX.XFRONT.XFE_O.NIN.n6 XRX.XFRONT.XFE_O.NIN.n4 5.57485
R6982 XRX.XFRONT.XFE_O.NIN.n15 XRX.XFRONT.XFE_O.NIN.n14 5.38537
R6983 XRX.XFRONT.XFE_O.NIN.n2 XRX.XFRONT.XFE_O.NIN.n1 5.38537
R6984 XRX.XFRONT.XFE_O.NIN.n9 XRX.XFRONT.XFE_O.NIN.n3 5.38537
R6985 XRX.XFRONT.XFE_O.NIN.n8 XRX.XFRONT.XFE_O.NIN.n7 5.38537
R6986 XRX.XFRONT.XFE_O.NIN.n6 XRX.XFRONT.XFE_O.NIN.n5 5.38537
R6987 XRX.XFRONT.XFE_O.NIN.n17 XRX.XFRONT.XFE_O.NIN.n16 5.38537
R6988 XRX.XFRONT.XFE_O.NIN.n19 XRX.XFRONT.XFE_O.NIN.n18 5.38537
R6989 XRX.XFRONT.XFE_O.NIN.n11 XRX.XFRONT.XFE_O.NIN.n10 5.32067
R6990 XRX.XFRONT.XFE_O.NIN.n21 XRX.XFRONT.XFE_O.NIN.n13 1.95702
R6991 XRX.XFRONT.XFE_O.NIN.n10 XRX.XFRONT.XFE_O.NIN.t13 0.228
R6992 XRX.XFRONT.XFE_O.NIN.n10 XRX.XFRONT.XFE_O.NIN.t14 0.228
R6993 XRX.XFRONT.XFE_O.NIN.n14 XRX.XFRONT.XFE_O.NIN.t21 0.20525
R6994 XRX.XFRONT.XFE_O.NIN.n14 XRX.XFRONT.XFE_O.NIN.t22 0.20525
R6995 XRX.XFRONT.XFE_O.NIN.n0 XRX.XFRONT.XFE_O.NIN.t5 0.20525
R6996 XRX.XFRONT.XFE_O.NIN.n0 XRX.XFRONT.XFE_O.NIN.t4 0.20525
R6997 XRX.XFRONT.XFE_O.NIN.n1 XRX.XFRONT.XFE_O.NIN.t7 0.20525
R6998 XRX.XFRONT.XFE_O.NIN.n1 XRX.XFRONT.XFE_O.NIN.t6 0.20525
R6999 XRX.XFRONT.XFE_O.NIN.n3 XRX.XFRONT.XFE_O.NIN.t9 0.20525
R7000 XRX.XFRONT.XFE_O.NIN.n3 XRX.XFRONT.XFE_O.NIN.t8 0.20525
R7001 XRX.XFRONT.XFE_O.NIN.n7 XRX.XFRONT.XFE_O.NIN.t11 0.20525
R7002 XRX.XFRONT.XFE_O.NIN.n7 XRX.XFRONT.XFE_O.NIN.t10 0.20525
R7003 XRX.XFRONT.XFE_O.NIN.n5 XRX.XFRONT.XFE_O.NIN.t1 0.20525
R7004 XRX.XFRONT.XFE_O.NIN.n5 XRX.XFRONT.XFE_O.NIN.t0 0.20525
R7005 XRX.XFRONT.XFE_O.NIN.n4 XRX.XFRONT.XFE_O.NIN.t3 0.20525
R7006 XRX.XFRONT.XFE_O.NIN.n4 XRX.XFRONT.XFE_O.NIN.t2 0.20525
R7007 XRX.XFRONT.XFE_O.NIN.n16 XRX.XFRONT.XFE_O.NIN.t19 0.20525
R7008 XRX.XFRONT.XFE_O.NIN.n16 XRX.XFRONT.XFE_O.NIN.t20 0.20525
R7009 XRX.XFRONT.XFE_O.NIN.n18 XRX.XFRONT.XFE_O.NIN.t17 0.20525
R7010 XRX.XFRONT.XFE_O.NIN.n18 XRX.XFRONT.XFE_O.NIN.t18 0.20525
R7011 XRX.XFRONT.XFE_O.NIN.n17 XRX.XFRONT.XFE_O.NIN.n15 0.189974
R7012 XRX.XFRONT.XFE_O.NIN.n8 XRX.XFRONT.XFE_O.NIN.n6 0.189974
R7013 XRX.XFRONT.XFE_O.NIN.n9 XRX.XFRONT.XFE_O.NIN.n8 0.189974
R7014 XRX.XFRONT.XFE_O.NIN.n9 XRX.XFRONT.XFE_O.NIN.n2 0.189974
R7015 XRX.XFRONT.XFE_O.NIN.n20 XRX.XFRONT.XFE_O.NIN.n19 0.0952368
R7016 XRX.XFRONT.XFE_O.NIN.n20 XRX.XFRONT.XFE_O.NIN.n17 0.0952368
R7017 XRX.XFRONT.XFE_O.NIN.n12 XRX.XFRONT.XFE_O.NIN.n11 0.0952368
R7018 XRX.XFRONT.XFE_O.NIN XRX.XFRONT.XFE_O.NIN.n21 0.0396304
R7019 XRX.XFRONT.XFE_O.NIP.n10 XRX.XFRONT.XFE_O.NIP.n9 20.2309
R7020 XRX.XFRONT.XFE_O.NIP.n10 XRX.XFRONT.XFE_O.NIP.n6 14.1657
R7021 XRX.XFRONT.XFE_O.NIP.n21 XRX.XFRONT.XFE_O.NIP.n20 10.957
R7022 XRX.XFRONT.XFE_O.NIP.n1 XRX.XFRONT.XFE_O.NIP.t19 5.7796
R7023 XRX.XFRONT.XFE_O.NIP.n5 XRX.XFRONT.XFE_O.NIP.t12 5.7796
R7024 XRX.XFRONT.XFE_O.NIP.n8 XRX.XFRONT.XFE_O.NIP.t11 5.73764
R7025 XRX.XFRONT.XFE_O.NIP.n9 XRX.XFRONT.XFE_O.NIP.t8 5.6429
R7026 XRX.XFRONT.XFE_O.NIP.n13 XRX.XFRONT.XFE_O.NIP.n11 5.57485
R7027 XRX.XFRONT.XFE_O.NIP.n17 XRX.XFRONT.XFE_O.NIP.n15 5.57485
R7028 XRX.XFRONT.XFE_O.NIP.n13 XRX.XFRONT.XFE_O.NIP.n12 5.38537
R7029 XRX.XFRONT.XFE_O.NIP.n20 XRX.XFRONT.XFE_O.NIP.n14 5.38537
R7030 XRX.XFRONT.XFE_O.NIP.n19 XRX.XFRONT.XFE_O.NIP.n18 5.38537
R7031 XRX.XFRONT.XFE_O.NIP.n17 XRX.XFRONT.XFE_O.NIP.n16 5.38537
R7032 XRX.XFRONT.XFE_O.NIP.n1 XRX.XFRONT.XFE_O.NIP.n0 5.38537
R7033 XRX.XFRONT.XFE_O.NIP.n3 XRX.XFRONT.XFE_O.NIP.n2 5.38537
R7034 XRX.XFRONT.XFE_O.NIP.n5 XRX.XFRONT.XFE_O.NIP.n4 5.38537
R7035 XRX.XFRONT.XFE_O.NIP.n8 XRX.XFRONT.XFE_O.NIP.n7 5.32067
R7036 XRX.XFRONT.XFE_O.NIP.n21 XRX.XFRONT.XFE_O.NIP.n10 1.05702
R7037 XRX.XFRONT.XFE_O.NIP.n7 XRX.XFRONT.XFE_O.NIP.t9 0.228
R7038 XRX.XFRONT.XFE_O.NIP.n7 XRX.XFRONT.XFE_O.NIP.t10 0.228
R7039 XRX.XFRONT.XFE_O.NIP.n11 XRX.XFRONT.XFE_O.NIP.t21 0.20525
R7040 XRX.XFRONT.XFE_O.NIP.n11 XRX.XFRONT.XFE_O.NIP.t20 0.20525
R7041 XRX.XFRONT.XFE_O.NIP.n12 XRX.XFRONT.XFE_O.NIP.t4 0.20525
R7042 XRX.XFRONT.XFE_O.NIP.n12 XRX.XFRONT.XFE_O.NIP.t22 0.20525
R7043 XRX.XFRONT.XFE_O.NIP.n14 XRX.XFRONT.XFE_O.NIP.t6 0.20525
R7044 XRX.XFRONT.XFE_O.NIP.n14 XRX.XFRONT.XFE_O.NIP.t5 0.20525
R7045 XRX.XFRONT.XFE_O.NIP.n18 XRX.XFRONT.XFE_O.NIP.t0 0.20525
R7046 XRX.XFRONT.XFE_O.NIP.n18 XRX.XFRONT.XFE_O.NIP.t7 0.20525
R7047 XRX.XFRONT.XFE_O.NIP.n16 XRX.XFRONT.XFE_O.NIP.t2 0.20525
R7048 XRX.XFRONT.XFE_O.NIP.n16 XRX.XFRONT.XFE_O.NIP.t1 0.20525
R7049 XRX.XFRONT.XFE_O.NIP.n15 XRX.XFRONT.XFE_O.NIP.t23 0.20525
R7050 XRX.XFRONT.XFE_O.NIP.n15 XRX.XFRONT.XFE_O.NIP.t3 0.20525
R7051 XRX.XFRONT.XFE_O.NIP.n0 XRX.XFRONT.XFE_O.NIP.t17 0.20525
R7052 XRX.XFRONT.XFE_O.NIP.n0 XRX.XFRONT.XFE_O.NIP.t18 0.20525
R7053 XRX.XFRONT.XFE_O.NIP.n2 XRX.XFRONT.XFE_O.NIP.t15 0.20525
R7054 XRX.XFRONT.XFE_O.NIP.n2 XRX.XFRONT.XFE_O.NIP.t16 0.20525
R7055 XRX.XFRONT.XFE_O.NIP.n4 XRX.XFRONT.XFE_O.NIP.t13 0.20525
R7056 XRX.XFRONT.XFE_O.NIP.n4 XRX.XFRONT.XFE_O.NIP.t14 0.20525
R7057 XRX.XFRONT.XFE_O.NIP.n3 XRX.XFRONT.XFE_O.NIP.n1 0.189974
R7058 XRX.XFRONT.XFE_O.NIP.n19 XRX.XFRONT.XFE_O.NIP.n17 0.189974
R7059 XRX.XFRONT.XFE_O.NIP.n20 XRX.XFRONT.XFE_O.NIP.n19 0.189974
R7060 XRX.XFRONT.XFE_O.NIP.n20 XRX.XFRONT.XFE_O.NIP.n13 0.189974
R7061 XRX.XFRONT.XFE_O.NIP.n6 XRX.XFRONT.XFE_O.NIP.n5 0.0952368
R7062 XRX.XFRONT.XFE_O.NIP.n6 XRX.XFRONT.XFE_O.NIP.n3 0.0952368
R7063 XRX.XFRONT.XFE_O.NIP.n9 XRX.XFRONT.XFE_O.NIP.n8 0.0952368
R7064 XRX.XFRONT.XFE_O.NIP XRX.XFRONT.XFE_O.NIP.n21 0.0396304
R7065 XRX.XFRONT.XFE_E.NIP.n20 XRX.XFRONT.XFE_E.NIP.n19 20.2309
R7066 XRX.XFRONT.XFE_E.NIP.n20 XRX.XFRONT.XFE_E.NIP.n16 14.1657
R7067 XRX.XFRONT.XFE_E.NIP XRX.XFRONT.XFE_E.NIP.n9 10.9962
R7068 XRX.XFRONT.XFE_E.NIP.n11 XRX.XFRONT.XFE_E.NIP.t7 5.7796
R7069 XRX.XFRONT.XFE_E.NIP.n13 XRX.XFRONT.XFE_E.NIP.t0 5.7796
R7070 XRX.XFRONT.XFE_E.NIP.n18 XRX.XFRONT.XFE_E.NIP.t17 5.73764
R7071 XRX.XFRONT.XFE_E.NIP.n19 XRX.XFRONT.XFE_E.NIP.t20 5.6429
R7072 XRX.XFRONT.XFE_E.NIP.n2 XRX.XFRONT.XFE_E.NIP.n0 5.57485
R7073 XRX.XFRONT.XFE_E.NIP.n8 XRX.XFRONT.XFE_E.NIP.n6 5.57485
R7074 XRX.XFRONT.XFE_E.NIP.n2 XRX.XFRONT.XFE_E.NIP.n1 5.38537
R7075 XRX.XFRONT.XFE_E.NIP.n4 XRX.XFRONT.XFE_E.NIP.n3 5.38537
R7076 XRX.XFRONT.XFE_E.NIP.n9 XRX.XFRONT.XFE_E.NIP.n5 5.38537
R7077 XRX.XFRONT.XFE_E.NIP.n8 XRX.XFRONT.XFE_E.NIP.n7 5.38537
R7078 XRX.XFRONT.XFE_E.NIP.n11 XRX.XFRONT.XFE_E.NIP.n10 5.38537
R7079 XRX.XFRONT.XFE_E.NIP.n15 XRX.XFRONT.XFE_E.NIP.n14 5.38537
R7080 XRX.XFRONT.XFE_E.NIP.n13 XRX.XFRONT.XFE_E.NIP.n12 5.38537
R7081 XRX.XFRONT.XFE_E.NIP.n18 XRX.XFRONT.XFE_E.NIP.n17 5.32067
R7082 XRX.XFRONT.XFE_E.NIP XRX.XFRONT.XFE_E.NIP.n20 1.01789
R7083 XRX.XFRONT.XFE_E.NIP.n17 XRX.XFRONT.XFE_E.NIP.t18 0.228
R7084 XRX.XFRONT.XFE_E.NIP.n17 XRX.XFRONT.XFE_E.NIP.t19 0.228
R7085 XRX.XFRONT.XFE_E.NIP.n0 XRX.XFRONT.XFE_E.NIP.t12 0.20525
R7086 XRX.XFRONT.XFE_E.NIP.n0 XRX.XFRONT.XFE_E.NIP.t11 0.20525
R7087 XRX.XFRONT.XFE_E.NIP.n1 XRX.XFRONT.XFE_E.NIP.t8 0.20525
R7088 XRX.XFRONT.XFE_E.NIP.n1 XRX.XFRONT.XFE_E.NIP.t13 0.20525
R7089 XRX.XFRONT.XFE_E.NIP.n3 XRX.XFRONT.XFE_E.NIP.t10 0.20525
R7090 XRX.XFRONT.XFE_E.NIP.n3 XRX.XFRONT.XFE_E.NIP.t9 0.20525
R7091 XRX.XFRONT.XFE_E.NIP.n5 XRX.XFRONT.XFE_E.NIP.t15 0.20525
R7092 XRX.XFRONT.XFE_E.NIP.n5 XRX.XFRONT.XFE_E.NIP.t14 0.20525
R7093 XRX.XFRONT.XFE_E.NIP.n7 XRX.XFRONT.XFE_E.NIP.t21 0.20525
R7094 XRX.XFRONT.XFE_E.NIP.n7 XRX.XFRONT.XFE_E.NIP.t16 0.20525
R7095 XRX.XFRONT.XFE_E.NIP.n6 XRX.XFRONT.XFE_E.NIP.t23 0.20525
R7096 XRX.XFRONT.XFE_E.NIP.n6 XRX.XFRONT.XFE_E.NIP.t22 0.20525
R7097 XRX.XFRONT.XFE_E.NIP.n10 XRX.XFRONT.XFE_E.NIP.t5 0.20525
R7098 XRX.XFRONT.XFE_E.NIP.n10 XRX.XFRONT.XFE_E.NIP.t6 0.20525
R7099 XRX.XFRONT.XFE_E.NIP.n14 XRX.XFRONT.XFE_E.NIP.t3 0.20525
R7100 XRX.XFRONT.XFE_E.NIP.n14 XRX.XFRONT.XFE_E.NIP.t4 0.20525
R7101 XRX.XFRONT.XFE_E.NIP.n12 XRX.XFRONT.XFE_E.NIP.t1 0.20525
R7102 XRX.XFRONT.XFE_E.NIP.n12 XRX.XFRONT.XFE_E.NIP.t2 0.20525
R7103 XRX.XFRONT.XFE_E.NIP.n15 XRX.XFRONT.XFE_E.NIP.n13 0.189974
R7104 XRX.XFRONT.XFE_E.NIP.n9 XRX.XFRONT.XFE_E.NIP.n8 0.189974
R7105 XRX.XFRONT.XFE_E.NIP.n9 XRX.XFRONT.XFE_E.NIP.n4 0.189974
R7106 XRX.XFRONT.XFE_E.NIP.n4 XRX.XFRONT.XFE_E.NIP.n2 0.189974
R7107 XRX.XFRONT.XFE_E.NIP.n16 XRX.XFRONT.XFE_E.NIP.n15 0.0952368
R7108 XRX.XFRONT.XFE_E.NIP.n16 XRX.XFRONT.XFE_E.NIP.n11 0.0952368
R7109 XRX.XFRONT.XFE_E.NIP.n19 XRX.XFRONT.XFE_E.NIP.n18 0.0952368
R7110 XRX.XFRONT.XFE_E.NIN.n20 XRX.XFRONT.XFE_E.NIN.n19 19.957
R7111 XRX.XFRONT.XFE_E.NIN.n20 XRX.XFRONT.XFE_E.NIN.n16 12.3657
R7112 XRX.XFRONT.XFE_E.NIN XRX.XFRONT.XFE_E.NIN.n6 11.9744
R7113 XRX.XFRONT.XFE_E.NIN.n1 XRX.XFRONT.XFE_E.NIN.t10 5.7796
R7114 XRX.XFRONT.XFE_E.NIN.n3 XRX.XFRONT.XFE_E.NIN.t3 5.7796
R7115 XRX.XFRONT.XFE_E.NIN.n18 XRX.XFRONT.XFE_E.NIN.t18 5.73764
R7116 XRX.XFRONT.XFE_E.NIN.n19 XRX.XFRONT.XFE_E.NIN.t21 5.6429
R7117 XRX.XFRONT.XFE_E.NIN.n9 XRX.XFRONT.XFE_E.NIN.n7 5.57485
R7118 XRX.XFRONT.XFE_E.NIN.n15 XRX.XFRONT.XFE_E.NIN.n13 5.57485
R7119 XRX.XFRONT.XFE_E.NIN.n9 XRX.XFRONT.XFE_E.NIN.n8 5.38537
R7120 XRX.XFRONT.XFE_E.NIN.n11 XRX.XFRONT.XFE_E.NIN.n10 5.38537
R7121 XRX.XFRONT.XFE_E.NIN.n16 XRX.XFRONT.XFE_E.NIN.n12 5.38537
R7122 XRX.XFRONT.XFE_E.NIN.n15 XRX.XFRONT.XFE_E.NIN.n14 5.38537
R7123 XRX.XFRONT.XFE_E.NIN.n1 XRX.XFRONT.XFE_E.NIN.n0 5.38537
R7124 XRX.XFRONT.XFE_E.NIN.n5 XRX.XFRONT.XFE_E.NIN.n4 5.38537
R7125 XRX.XFRONT.XFE_E.NIN.n3 XRX.XFRONT.XFE_E.NIN.n2 5.38537
R7126 XRX.XFRONT.XFE_E.NIN.n18 XRX.XFRONT.XFE_E.NIN.n17 5.32067
R7127 XRX.XFRONT.XFE_E.NIN XRX.XFRONT.XFE_E.NIN.n20 1.91789
R7128 XRX.XFRONT.XFE_E.NIN.n17 XRX.XFRONT.XFE_E.NIN.t19 0.228
R7129 XRX.XFRONT.XFE_E.NIN.n17 XRX.XFRONT.XFE_E.NIN.t20 0.228
R7130 XRX.XFRONT.XFE_E.NIN.n7 XRX.XFRONT.XFE_E.NIN.t23 0.20525
R7131 XRX.XFRONT.XFE_E.NIN.n7 XRX.XFRONT.XFE_E.NIN.t22 0.20525
R7132 XRX.XFRONT.XFE_E.NIN.n8 XRX.XFRONT.XFE_E.NIN.t12 0.20525
R7133 XRX.XFRONT.XFE_E.NIN.n8 XRX.XFRONT.XFE_E.NIN.t11 0.20525
R7134 XRX.XFRONT.XFE_E.NIN.n10 XRX.XFRONT.XFE_E.NIN.t0 0.20525
R7135 XRX.XFRONT.XFE_E.NIN.n10 XRX.XFRONT.XFE_E.NIN.t13 0.20525
R7136 XRX.XFRONT.XFE_E.NIN.n12 XRX.XFRONT.XFE_E.NIN.t2 0.20525
R7137 XRX.XFRONT.XFE_E.NIN.n12 XRX.XFRONT.XFE_E.NIN.t1 0.20525
R7138 XRX.XFRONT.XFE_E.NIN.n14 XRX.XFRONT.XFE_E.NIN.t16 0.20525
R7139 XRX.XFRONT.XFE_E.NIN.n14 XRX.XFRONT.XFE_E.NIN.t15 0.20525
R7140 XRX.XFRONT.XFE_E.NIN.n13 XRX.XFRONT.XFE_E.NIN.t14 0.20525
R7141 XRX.XFRONT.XFE_E.NIN.n13 XRX.XFRONT.XFE_E.NIN.t17 0.20525
R7142 XRX.XFRONT.XFE_E.NIN.n0 XRX.XFRONT.XFE_E.NIN.t8 0.20525
R7143 XRX.XFRONT.XFE_E.NIN.n0 XRX.XFRONT.XFE_E.NIN.t9 0.20525
R7144 XRX.XFRONT.XFE_E.NIN.n4 XRX.XFRONT.XFE_E.NIN.t6 0.20525
R7145 XRX.XFRONT.XFE_E.NIN.n4 XRX.XFRONT.XFE_E.NIN.t7 0.20525
R7146 XRX.XFRONT.XFE_E.NIN.n2 XRX.XFRONT.XFE_E.NIN.t4 0.20525
R7147 XRX.XFRONT.XFE_E.NIN.n2 XRX.XFRONT.XFE_E.NIN.t5 0.20525
R7148 XRX.XFRONT.XFE_E.NIN.n5 XRX.XFRONT.XFE_E.NIN.n3 0.189974
R7149 XRX.XFRONT.XFE_E.NIN.n16 XRX.XFRONT.XFE_E.NIN.n15 0.189974
R7150 XRX.XFRONT.XFE_E.NIN.n16 XRX.XFRONT.XFE_E.NIN.n11 0.189974
R7151 XRX.XFRONT.XFE_E.NIN.n11 XRX.XFRONT.XFE_E.NIN.n9 0.189974
R7152 XRX.XFRONT.XFE_E.NIN.n6 XRX.XFRONT.XFE_E.NIN.n5 0.0952368
R7153 XRX.XFRONT.XFE_E.NIN.n6 XRX.XFRONT.XFE_E.NIN.n1 0.0952368
R7154 XRX.XFRONT.XFE_E.NIN.n19 XRX.XFRONT.XFE_E.NIN.n18 0.0952368
R7155 XRX.XFRONT.XFE_O.HB.n28 XRX.XFRONT.XFE_O.HB.t21 142.571
R7156 XRX.XFRONT.XFE_O.HB.n5 XRX.XFRONT.XFE_O.HB.t17 113.632
R7157 XRX.XFRONT.XFE_O.HB.n0 XRX.XFRONT.XFE_O.HB.t24 113.632
R7158 XRX.XFRONT.XFE_O.HB.n30 XRX.XFRONT.XFE_O.HB.t25 113.632
R7159 XRX.XFRONT.XFE_O.HB.n7 XRX.XFRONT.XFE_O.HB.t19 109.174
R7160 XRX.XFRONT.XFE_O.HB.n8 XRX.XFRONT.XFE_O.HB.t20 109.174
R7161 XRX.XFRONT.XFE_O.HB.n6 XRX.XFRONT.XFE_O.HB.t18 109.174
R7162 XRX.XFRONT.XFE_O.HB.n1 XRX.XFRONT.XFE_O.HB.t23 109.174
R7163 XRX.XFRONT.XFE_O.HB.n2 XRX.XFRONT.XFE_O.HB.t22 109.174
R7164 XRX.XFRONT.XFE_O.HB.n33 XRX.XFRONT.XFE_O.HB.t28 109.174
R7165 XRX.XFRONT.XFE_O.HB.n32 XRX.XFRONT.XFE_O.HB.t27 109.174
R7166 XRX.XFRONT.XFE_O.HB.n31 XRX.XFRONT.XFE_O.HB.t26 109.174
R7167 XRX.XFRONT.XFE_O.HB.n9 XRX.XFRONT.XFE_O.HB.n8 18.5179
R7168 XRX.XFRONT.XFE_O.HB.n7 XRX.XFRONT.XFE_O.HB.n4 18.4942
R7169 XRX.XFRONT.XFE_O.HB.n3 XRX.XFRONT.XFE_O.HB.n2 18.4942
R7170 XRX.XFRONT.XFE_O.HB.n34 XRX.XFRONT.XFE_O.HB.n33 18.4942
R7171 XRX.XFRONT.XFE_O.HB.n32 XRX.XFRONT.XFE_O.HB.n29 18.4942
R7172 XRX.XFRONT.XFE_O.HB.n27 XRX.XFRONT.XFE_O.HB.n26 17.4527
R7173 XRX.XFRONT.XFE_O.HB.n10 XRX.XFRONT.XFE_O.HB.n3 16.4663
R7174 XRX.XFRONT.XFE_O.HB.n35 XRX.XFRONT.XFE_O.HB.n34 15.8194
R7175 XRX.XFRONT.XFE_O.HB.n23 XRX.XFRONT.XFE_O.HB.t10 15.1863
R7176 XRX.XFRONT.XFE_O.HB.n10 XRX.XFRONT.XFE_O.HB.n9 14.6157
R7177 XRX.XFRONT.XFE_O.HB.n28 XRX.XFRONT.XFE_O.HB.n27 13.344
R7178 XRX.XFRONT.XFE_O.HB.n22 XRX.XFRONT.XFE_O.HB.n21 12.757
R7179 XRX.XFRONT.XFE_O.HB.n7 XRX.XFRONT.XFE_O.HB.n6 11.6805
R7180 XRX.XFRONT.XFE_O.HB.n8 XRX.XFRONT.XFE_O.HB.n7 11.6805
R7181 XRX.XFRONT.XFE_O.HB.n2 XRX.XFRONT.XFE_O.HB.n1 11.6805
R7182 XRX.XFRONT.XFE_O.HB.n33 XRX.XFRONT.XFE_O.HB.n32 11.6805
R7183 XRX.XFRONT.XFE_O.HB.n32 XRX.XFRONT.XFE_O.HB.n31 11.6805
R7184 XRX.XFRONT.XFE_O.HB.n18 XRX.XFRONT.XFE_O.HB.n17 9.43093
R7185 XRX.XFRONT.XFE_O.HB.n5 XRX.XFRONT.XFE_O.HB.n4 7.17687
R7186 XRX.XFRONT.XFE_O.HB.n3 XRX.XFRONT.XFE_O.HB.n0 7.17687
R7187 XRX.XFRONT.XFE_O.HB.n30 XRX.XFRONT.XFE_O.HB.n29 7.17687
R7188 XRX.XFRONT.XFE_O.HB.n12 XRX.XFRONT.XFE_O.HB.t9 5.7796
R7189 XRX.XFRONT.XFE_O.HB.n16 XRX.XFRONT.XFE_O.HB.t2 5.7796
R7190 XRX.XFRONT.XFE_O.HB.n20 XRX.XFRONT.XFE_O.HB.t0 5.73764
R7191 XRX.XFRONT.XFE_O.HB.n25 XRX.XFRONT.XFE_O.HB.t1 5.73764
R7192 XRX.XFRONT.XFE_O.HB.n26 XRX.XFRONT.XFE_O.HB.t14 5.71396
R7193 XRX.XFRONT.XFE_O.HB.n21 XRX.XFRONT.XFE_O.HB.t13 5.6429
R7194 XRX.XFRONT.XFE_O.HB.n12 XRX.XFRONT.XFE_O.HB.n11 5.38537
R7195 XRX.XFRONT.XFE_O.HB.n14 XRX.XFRONT.XFE_O.HB.n13 5.38537
R7196 XRX.XFRONT.XFE_O.HB.n16 XRX.XFRONT.XFE_O.HB.n15 5.38537
R7197 XRX.XFRONT.XFE_O.HB.n20 XRX.XFRONT.XFE_O.HB.n19 5.32067
R7198 XRX.XFRONT.XFE_O.HB.n25 XRX.XFRONT.XFE_O.HB.n24 5.32067
R7199 XRX.XFRONT.XFE_O.HB.n6 XRX.XFRONT.XFE_O.HB.n5 4.42851
R7200 XRX.XFRONT.XFE_O.HB.n1 XRX.XFRONT.XFE_O.HB.n0 4.42851
R7201 XRX.XFRONT.XFE_O.HB.n31 XRX.XFRONT.XFE_O.HB.n30 4.42851
R7202 XRX.XFRONT.XFE_O.HB.n18 XRX.XFRONT.XFE_O.HB.n10 3.48311
R7203 XRX.XFRONT.XFE_O.HB.n27 XRX.XFRONT.XFE_O.HB.n23 2.34833
R7204 XRX.XFRONT.XFE_O.HB.n35 XRX.XFRONT.XFE_O.HB.n28 1.17441
R7205 XRX.XFRONT.XFE_O.HB.n22 XRX.XFRONT.XFE_O.HB.n18 1.17441
R7206 XRX.XFRONT.XFE_O.HB.n23 XRX.XFRONT.XFE_O.HB.n22 0.587457
R7207 XRX.XFRONT.XFE_O.HB.n19 XRX.XFRONT.XFE_O.HB.t12 0.228
R7208 XRX.XFRONT.XFE_O.HB.n19 XRX.XFRONT.XFE_O.HB.t11 0.228
R7209 XRX.XFRONT.XFE_O.HB.n24 XRX.XFRONT.XFE_O.HB.t16 0.228
R7210 XRX.XFRONT.XFE_O.HB.n24 XRX.XFRONT.XFE_O.HB.t15 0.228
R7211 XRX.XFRONT.XFE_O.HB.n11 XRX.XFRONT.XFE_O.HB.t7 0.20525
R7212 XRX.XFRONT.XFE_O.HB.n11 XRX.XFRONT.XFE_O.HB.t8 0.20525
R7213 XRX.XFRONT.XFE_O.HB.n13 XRX.XFRONT.XFE_O.HB.t5 0.20525
R7214 XRX.XFRONT.XFE_O.HB.n13 XRX.XFRONT.XFE_O.HB.t6 0.20525
R7215 XRX.XFRONT.XFE_O.HB.n15 XRX.XFRONT.XFE_O.HB.t3 0.20525
R7216 XRX.XFRONT.XFE_O.HB.n15 XRX.XFRONT.XFE_O.HB.t4 0.20525
R7217 XRX.XFRONT.XFE_O.HB.n14 XRX.XFRONT.XFE_O.HB.n12 0.189974
R7218 XRX.XFRONT.XFE_O.HB.n34 XRX.XFRONT.XFE_O.HB.n29 0.1205
R7219 XRX.XFRONT.XFE_O.HB.n17 XRX.XFRONT.XFE_O.HB.n16 0.0952368
R7220 XRX.XFRONT.XFE_O.HB.n17 XRX.XFRONT.XFE_O.HB.n14 0.0952368
R7221 XRX.XFRONT.XFE_O.HB.n21 XRX.XFRONT.XFE_O.HB.n20 0.0952368
R7222 XRX.XFRONT.XFE_O.HB.n9 XRX.XFRONT.XFE_O.HB.n4 0.0785
R7223 XRX.XFRONT.XFE_O.HB XRX.XFRONT.XFE_O.HB.n35 0.0396304
R7224 XRX.XFRONT.XFE_O.HB.n26 XRX.XFRONT.XFE_O.HB.n25 0.0241842
R7225 XRX.XFRONT.XFE_O.H.n6 XRX.XFRONT.XFE_O.H.t17 142.148
R7226 XRX.XFRONT.XFE_O.H.n1 XRX.XFRONT.XFE_O.H.t25 113.632
R7227 XRX.XFRONT.XFE_O.H.n30 XRX.XFRONT.XFE_O.H.t18 113.632
R7228 XRX.XFRONT.XFE_O.H.n24 XRX.XFRONT.XFE_O.H.t28 113.632
R7229 XRX.XFRONT.XFE_O.H.n2 XRX.XFRONT.XFE_O.H.t24 109.174
R7230 XRX.XFRONT.XFE_O.H.n3 XRX.XFRONT.XFE_O.H.t23 109.174
R7231 XRX.XFRONT.XFE_O.H.n0 XRX.XFRONT.XFE_O.H.t22 109.174
R7232 XRX.XFRONT.XFE_O.H.n32 XRX.XFRONT.XFE_O.H.t20 109.174
R7233 XRX.XFRONT.XFE_O.H.n33 XRX.XFRONT.XFE_O.H.t21 109.174
R7234 XRX.XFRONT.XFE_O.H.n31 XRX.XFRONT.XFE_O.H.t19 109.174
R7235 XRX.XFRONT.XFE_O.H.n25 XRX.XFRONT.XFE_O.H.t27 109.174
R7236 XRX.XFRONT.XFE_O.H.n26 XRX.XFRONT.XFE_O.H.t26 109.174
R7237 XRX.XFRONT.XFE_O.H.n5 XRX.XFRONT.XFE_O.H.n0 18.5179
R7238 XRX.XFRONT.XFE_O.H.n34 XRX.XFRONT.XFE_O.H.n33 18.5179
R7239 XRX.XFRONT.XFE_O.H.n4 XRX.XFRONT.XFE_O.H.n3 18.4942
R7240 XRX.XFRONT.XFE_O.H.n32 XRX.XFRONT.XFE_O.H.n29 18.4942
R7241 XRX.XFRONT.XFE_O.H.n27 XRX.XFRONT.XFE_O.H.n26 18.4942
R7242 XRX.XFRONT.XFE_O.H.n10 XRX.XFRONT.XFE_O.H.n9 17.7266
R7243 XRX.XFRONT.XFE_O.H.n6 XRX.XFRONT.XFE_O.H.n5 16.7679
R7244 XRX.XFRONT.XFE_O.H.n28 XRX.XFRONT.XFE_O.H.n27 16.1533
R7245 XRX.XFRONT.XFE_O.H.n11 XRX.XFRONT.XFE_O.H.t0 15.3418
R7246 XRX.XFRONT.XFE_O.H.n35 XRX.XFRONT.XFE_O.H.n34 14.3418
R7247 XRX.XFRONT.XFE_O.H.n10 XRX.XFRONT.XFE_O.H.n6 13.657
R7248 XRX.XFRONT.XFE_O.H.n15 XRX.XFRONT.XFE_O.H.n14 13.0309
R7249 XRX.XFRONT.XFE_O.H.n3 XRX.XFRONT.XFE_O.H.n2 11.6805
R7250 XRX.XFRONT.XFE_O.H.n3 XRX.XFRONT.XFE_O.H.n0 11.6805
R7251 XRX.XFRONT.XFE_O.H.n32 XRX.XFRONT.XFE_O.H.n31 11.6805
R7252 XRX.XFRONT.XFE_O.H.n33 XRX.XFRONT.XFE_O.H.n32 11.6805
R7253 XRX.XFRONT.XFE_O.H.n26 XRX.XFRONT.XFE_O.H.n25 11.6805
R7254 XRX.XFRONT.XFE_O.H.n23 XRX.XFRONT.XFE_O.H.n22 9.70485
R7255 XRX.XFRONT.XFE_O.H.n4 XRX.XFRONT.XFE_O.H.n1 7.17687
R7256 XRX.XFRONT.XFE_O.H.n30 XRX.XFRONT.XFE_O.H.n29 7.17687
R7257 XRX.XFRONT.XFE_O.H.n27 XRX.XFRONT.XFE_O.H.n24 7.17687
R7258 XRX.XFRONT.XFE_O.H.n17 XRX.XFRONT.XFE_O.H.t12 5.7796
R7259 XRX.XFRONT.XFE_O.H.n21 XRX.XFRONT.XFE_O.H.t5 5.7796
R7260 XRX.XFRONT.XFE_O.H.n13 XRX.XFRONT.XFE_O.H.t4 5.73764
R7261 XRX.XFRONT.XFE_O.H.n8 XRX.XFRONT.XFE_O.H.t16 5.73764
R7262 XRX.XFRONT.XFE_O.H.n14 XRX.XFRONT.XFE_O.H.t1 5.6429
R7263 XRX.XFRONT.XFE_O.H.n9 XRX.XFRONT.XFE_O.H.t15 5.6429
R7264 XRX.XFRONT.XFE_O.H.n17 XRX.XFRONT.XFE_O.H.n16 5.38537
R7265 XRX.XFRONT.XFE_O.H.n19 XRX.XFRONT.XFE_O.H.n18 5.38537
R7266 XRX.XFRONT.XFE_O.H.n21 XRX.XFRONT.XFE_O.H.n20 5.38537
R7267 XRX.XFRONT.XFE_O.H.n13 XRX.XFRONT.XFE_O.H.n12 5.32067
R7268 XRX.XFRONT.XFE_O.H.n8 XRX.XFRONT.XFE_O.H.n7 5.32067
R7269 XRX.XFRONT.XFE_O.H.n2 XRX.XFRONT.XFE_O.H.n1 4.42851
R7270 XRX.XFRONT.XFE_O.H.n31 XRX.XFRONT.XFE_O.H.n30 4.42851
R7271 XRX.XFRONT.XFE_O.H.n25 XRX.XFRONT.XFE_O.H.n24 4.42851
R7272 XRX.XFRONT.XFE_O.H.n28 XRX.XFRONT.XFE_O.H.n23 2.97441
R7273 XRX.XFRONT.XFE_O.H.n11 XRX.XFRONT.XFE_O.H.n10 2.73963
R7274 XRX.XFRONT.XFE_O.H.n23 XRX.XFRONT.XFE_O.H.n15 1.17441
R7275 XRX.XFRONT.XFE_O.H.n35 XRX.XFRONT.XFE_O.H.n28 0.587457
R7276 XRX.XFRONT.XFE_O.H.n15 XRX.XFRONT.XFE_O.H.n11 0.391804
R7277 XRX.XFRONT.XFE_O.H.n12 XRX.XFRONT.XFE_O.H.t2 0.228
R7278 XRX.XFRONT.XFE_O.H.n12 XRX.XFRONT.XFE_O.H.t3 0.228
R7279 XRX.XFRONT.XFE_O.H.n7 XRX.XFRONT.XFE_O.H.t14 0.228
R7280 XRX.XFRONT.XFE_O.H.n7 XRX.XFRONT.XFE_O.H.t13 0.228
R7281 XRX.XFRONT.XFE_O.H.n16 XRX.XFRONT.XFE_O.H.t10 0.20525
R7282 XRX.XFRONT.XFE_O.H.n16 XRX.XFRONT.XFE_O.H.t11 0.20525
R7283 XRX.XFRONT.XFE_O.H.n18 XRX.XFRONT.XFE_O.H.t8 0.20525
R7284 XRX.XFRONT.XFE_O.H.n18 XRX.XFRONT.XFE_O.H.t9 0.20525
R7285 XRX.XFRONT.XFE_O.H.n20 XRX.XFRONT.XFE_O.H.t6 0.20525
R7286 XRX.XFRONT.XFE_O.H.n20 XRX.XFRONT.XFE_O.H.t7 0.20525
R7287 XRX.XFRONT.XFE_O.H.n19 XRX.XFRONT.XFE_O.H.n17 0.189974
R7288 XRX.XFRONT.XFE_O.H.n22 XRX.XFRONT.XFE_O.H.n21 0.0952368
R7289 XRX.XFRONT.XFE_O.H.n22 XRX.XFRONT.XFE_O.H.n19 0.0952368
R7290 XRX.XFRONT.XFE_O.H.n14 XRX.XFRONT.XFE_O.H.n13 0.0952368
R7291 XRX.XFRONT.XFE_O.H.n9 XRX.XFRONT.XFE_O.H.n8 0.0952368
R7292 XRX.XFRONT.XFE_O.H.n5 XRX.XFRONT.XFE_O.H.n4 0.0785
R7293 XRX.XFRONT.XFE_O.H.n34 XRX.XFRONT.XFE_O.H.n29 0.0785
R7294 XRX.XFRONT.XFE_O.H XRX.XFRONT.XFE_O.H.n35 0.0396304
R7295 XRX.XFRONT.XFE_E.H.n12 XRX.XFRONT.XFE_E.H.t21 142.148
R7296 XRX.XFRONT.XFE_E.H.n1 XRX.XFRONT.XFE_E.H.t20 113.632
R7297 XRX.XFRONT.XFE_E.H.n30 XRX.XFRONT.XFE_E.H.t22 113.632
R7298 XRX.XFRONT.XFE_E.H.n7 XRX.XFRONT.XFE_E.H.t25 113.632
R7299 XRX.XFRONT.XFE_E.H.n2 XRX.XFRONT.XFE_E.H.t19 109.174
R7300 XRX.XFRONT.XFE_E.H.n3 XRX.XFRONT.XFE_E.H.t18 109.174
R7301 XRX.XFRONT.XFE_E.H.n0 XRX.XFRONT.XFE_E.H.t17 109.174
R7302 XRX.XFRONT.XFE_E.H.n32 XRX.XFRONT.XFE_E.H.t24 109.174
R7303 XRX.XFRONT.XFE_E.H.n31 XRX.XFRONT.XFE_E.H.t23 109.174
R7304 XRX.XFRONT.XFE_E.H.n9 XRX.XFRONT.XFE_E.H.t27 109.174
R7305 XRX.XFRONT.XFE_E.H.n10 XRX.XFRONT.XFE_E.H.t28 109.174
R7306 XRX.XFRONT.XFE_E.H.n8 XRX.XFRONT.XFE_E.H.t26 109.174
R7307 XRX.XFRONT.XFE_E.H.n5 XRX.XFRONT.XFE_E.H.n0 18.5179
R7308 XRX.XFRONT.XFE_E.H.n11 XRX.XFRONT.XFE_E.H.n10 18.5179
R7309 XRX.XFRONT.XFE_E.H.n4 XRX.XFRONT.XFE_E.H.n3 18.4942
R7310 XRX.XFRONT.XFE_E.H.n33 XRX.XFRONT.XFE_E.H.n32 18.4942
R7311 XRX.XFRONT.XFE_E.H.n9 XRX.XFRONT.XFE_E.H.n6 18.4942
R7312 XRX.XFRONT.XFE_E.H.n16 XRX.XFRONT.XFE_E.H.n15 17.7266
R7313 XRX.XFRONT.XFE_E.H.n12 XRX.XFRONT.XFE_E.H.n11 16.7679
R7314 XRX.XFRONT.XFE_E.H.n34 XRX.XFRONT.XFE_E.H.n33 16.1533
R7315 XRX.XFRONT.XFE_E.H.n17 XRX.XFRONT.XFE_E.H.t16 15.3418
R7316 XRX.XFRONT.XFE_E.H XRX.XFRONT.XFE_E.H.n5 14.3809
R7317 XRX.XFRONT.XFE_E.H.n16 XRX.XFRONT.XFE_E.H.n12 13.657
R7318 XRX.XFRONT.XFE_E.H.n21 XRX.XFRONT.XFE_E.H.n20 13.0309
R7319 XRX.XFRONT.XFE_E.H.n3 XRX.XFRONT.XFE_E.H.n2 11.6805
R7320 XRX.XFRONT.XFE_E.H.n3 XRX.XFRONT.XFE_E.H.n0 11.6805
R7321 XRX.XFRONT.XFE_E.H.n32 XRX.XFRONT.XFE_E.H.n31 11.6805
R7322 XRX.XFRONT.XFE_E.H.n9 XRX.XFRONT.XFE_E.H.n8 11.6805
R7323 XRX.XFRONT.XFE_E.H.n10 XRX.XFRONT.XFE_E.H.n9 11.6805
R7324 XRX.XFRONT.XFE_E.H.n29 XRX.XFRONT.XFE_E.H.n28 9.70485
R7325 XRX.XFRONT.XFE_E.H.n4 XRX.XFRONT.XFE_E.H.n1 7.17687
R7326 XRX.XFRONT.XFE_E.H.n33 XRX.XFRONT.XFE_E.H.n30 7.17687
R7327 XRX.XFRONT.XFE_E.H.n7 XRX.XFRONT.XFE_E.H.n6 7.17687
R7328 XRX.XFRONT.XFE_E.H.n23 XRX.XFRONT.XFE_E.H.t9 5.7796
R7329 XRX.XFRONT.XFE_E.H.n25 XRX.XFRONT.XFE_E.H.t2 5.7796
R7330 XRX.XFRONT.XFE_E.H.n19 XRX.XFRONT.XFE_E.H.t12 5.73764
R7331 XRX.XFRONT.XFE_E.H.n14 XRX.XFRONT.XFE_E.H.t1 5.73764
R7332 XRX.XFRONT.XFE_E.H.n20 XRX.XFRONT.XFE_E.H.t13 5.6429
R7333 XRX.XFRONT.XFE_E.H.n15 XRX.XFRONT.XFE_E.H.t14 5.6429
R7334 XRX.XFRONT.XFE_E.H.n23 XRX.XFRONT.XFE_E.H.n22 5.38537
R7335 XRX.XFRONT.XFE_E.H.n27 XRX.XFRONT.XFE_E.H.n26 5.38537
R7336 XRX.XFRONT.XFE_E.H.n25 XRX.XFRONT.XFE_E.H.n24 5.38537
R7337 XRX.XFRONT.XFE_E.H.n19 XRX.XFRONT.XFE_E.H.n18 5.32067
R7338 XRX.XFRONT.XFE_E.H.n14 XRX.XFRONT.XFE_E.H.n13 5.32067
R7339 XRX.XFRONT.XFE_E.H.n2 XRX.XFRONT.XFE_E.H.n1 4.42851
R7340 XRX.XFRONT.XFE_E.H.n31 XRX.XFRONT.XFE_E.H.n30 4.42851
R7341 XRX.XFRONT.XFE_E.H.n8 XRX.XFRONT.XFE_E.H.n7 4.42851
R7342 XRX.XFRONT.XFE_E.H.n34 XRX.XFRONT.XFE_E.H.n29 2.97441
R7343 XRX.XFRONT.XFE_E.H.n17 XRX.XFRONT.XFE_E.H.n16 2.73963
R7344 XRX.XFRONT.XFE_E.H.n29 XRX.XFRONT.XFE_E.H.n21 1.17441
R7345 XRX.XFRONT.XFE_E.H XRX.XFRONT.XFE_E.H.n34 0.548326
R7346 XRX.XFRONT.XFE_E.H.n21 XRX.XFRONT.XFE_E.H.n17 0.391804
R7347 XRX.XFRONT.XFE_E.H.n18 XRX.XFRONT.XFE_E.H.t11 0.228
R7348 XRX.XFRONT.XFE_E.H.n18 XRX.XFRONT.XFE_E.H.t10 0.228
R7349 XRX.XFRONT.XFE_E.H.n13 XRX.XFRONT.XFE_E.H.t0 0.228
R7350 XRX.XFRONT.XFE_E.H.n13 XRX.XFRONT.XFE_E.H.t15 0.228
R7351 XRX.XFRONT.XFE_E.H.n22 XRX.XFRONT.XFE_E.H.t7 0.20525
R7352 XRX.XFRONT.XFE_E.H.n22 XRX.XFRONT.XFE_E.H.t8 0.20525
R7353 XRX.XFRONT.XFE_E.H.n26 XRX.XFRONT.XFE_E.H.t5 0.20525
R7354 XRX.XFRONT.XFE_E.H.n26 XRX.XFRONT.XFE_E.H.t6 0.20525
R7355 XRX.XFRONT.XFE_E.H.n24 XRX.XFRONT.XFE_E.H.t3 0.20525
R7356 XRX.XFRONT.XFE_E.H.n24 XRX.XFRONT.XFE_E.H.t4 0.20525
R7357 XRX.XFRONT.XFE_E.H.n27 XRX.XFRONT.XFE_E.H.n25 0.189974
R7358 XRX.XFRONT.XFE_E.H.n28 XRX.XFRONT.XFE_E.H.n27 0.0952368
R7359 XRX.XFRONT.XFE_E.H.n28 XRX.XFRONT.XFE_E.H.n23 0.0952368
R7360 XRX.XFRONT.XFE_E.H.n20 XRX.XFRONT.XFE_E.H.n19 0.0952368
R7361 XRX.XFRONT.XFE_E.H.n15 XRX.XFRONT.XFE_E.H.n14 0.0952368
R7362 XRX.XFRONT.XFE_E.H.n5 XRX.XFRONT.XFE_E.H.n4 0.0785
R7363 XRX.XFRONT.XFE_E.H.n11 XRX.XFRONT.XFE_E.H.n6 0.0785
R7364 XRX.XFRONT.XFE_E.HB.n34 XRX.XFRONT.XFE_E.HB.t17 142.571
R7365 XRX.XFRONT.XFE_E.HB.n1 XRX.XFRONT.XFE_E.HB.t25 113.632
R7366 XRX.XFRONT.XFE_E.HB.n11 XRX.XFRONT.XFE_E.HB.t21 113.632
R7367 XRX.XFRONT.XFE_E.HB.n6 XRX.XFRONT.XFE_E.HB.t26 113.632
R7368 XRX.XFRONT.XFE_E.HB.n2 XRX.XFRONT.XFE_E.HB.t24 109.174
R7369 XRX.XFRONT.XFE_E.HB.n3 XRX.XFRONT.XFE_E.HB.t23 109.174
R7370 XRX.XFRONT.XFE_E.HB.n4 XRX.XFRONT.XFE_E.HB.t22 109.174
R7371 XRX.XFRONT.XFE_E.HB.n12 XRX.XFRONT.XFE_E.HB.t20 109.174
R7372 XRX.XFRONT.XFE_E.HB.n13 XRX.XFRONT.XFE_E.HB.t19 109.174
R7373 XRX.XFRONT.XFE_E.HB.n10 XRX.XFRONT.XFE_E.HB.t18 109.174
R7374 XRX.XFRONT.XFE_E.HB.n8 XRX.XFRONT.XFE_E.HB.t28 109.174
R7375 XRX.XFRONT.XFE_E.HB.n7 XRX.XFRONT.XFE_E.HB.t27 109.174
R7376 XRX.XFRONT.XFE_E.HB.n15 XRX.XFRONT.XFE_E.HB.n10 18.5179
R7377 XRX.XFRONT.XFE_E.HB.n3 XRX.XFRONT.XFE_E.HB.n0 18.4942
R7378 XRX.XFRONT.XFE_E.HB.n5 XRX.XFRONT.XFE_E.HB.n4 18.4942
R7379 XRX.XFRONT.XFE_E.HB.n14 XRX.XFRONT.XFE_E.HB.n13 18.4942
R7380 XRX.XFRONT.XFE_E.HB.n9 XRX.XFRONT.XFE_E.HB.n8 18.4942
R7381 XRX.XFRONT.XFE_E.HB.n33 XRX.XFRONT.XFE_E.HB.n32 17.4527
R7382 XRX.XFRONT.XFE_E.HB.n16 XRX.XFRONT.XFE_E.HB.n9 16.4663
R7383 XRX.XFRONT.XFE_E.HB XRX.XFRONT.XFE_E.HB.n5 15.8585
R7384 XRX.XFRONT.XFE_E.HB.n29 XRX.XFRONT.XFE_E.HB.t0 15.1863
R7385 XRX.XFRONT.XFE_E.HB.n16 XRX.XFRONT.XFE_E.HB.n15 14.6157
R7386 XRX.XFRONT.XFE_E.HB.n34 XRX.XFRONT.XFE_E.HB.n33 13.344
R7387 XRX.XFRONT.XFE_E.HB.n28 XRX.XFRONT.XFE_E.HB.n27 12.757
R7388 XRX.XFRONT.XFE_E.HB.n3 XRX.XFRONT.XFE_E.HB.n2 11.6805
R7389 XRX.XFRONT.XFE_E.HB.n4 XRX.XFRONT.XFE_E.HB.n3 11.6805
R7390 XRX.XFRONT.XFE_E.HB.n13 XRX.XFRONT.XFE_E.HB.n12 11.6805
R7391 XRX.XFRONT.XFE_E.HB.n13 XRX.XFRONT.XFE_E.HB.n10 11.6805
R7392 XRX.XFRONT.XFE_E.HB.n8 XRX.XFRONT.XFE_E.HB.n7 11.6805
R7393 XRX.XFRONT.XFE_E.HB.n24 XRX.XFRONT.XFE_E.HB.n23 9.43093
R7394 XRX.XFRONT.XFE_E.HB.n1 XRX.XFRONT.XFE_E.HB.n0 7.17687
R7395 XRX.XFRONT.XFE_E.HB.n14 XRX.XFRONT.XFE_E.HB.n11 7.17687
R7396 XRX.XFRONT.XFE_E.HB.n9 XRX.XFRONT.XFE_E.HB.n6 7.17687
R7397 XRX.XFRONT.XFE_E.HB.n18 XRX.XFRONT.XFE_E.HB.t14 5.7796
R7398 XRX.XFRONT.XFE_E.HB.n20 XRX.XFRONT.XFE_E.HB.t7 5.7796
R7399 XRX.XFRONT.XFE_E.HB.n26 XRX.XFRONT.XFE_E.HB.t1 5.73764
R7400 XRX.XFRONT.XFE_E.HB.n31 XRX.XFRONT.XFE_E.HB.t15 5.73764
R7401 XRX.XFRONT.XFE_E.HB.n32 XRX.XFRONT.XFE_E.HB.t6 5.71396
R7402 XRX.XFRONT.XFE_E.HB.n27 XRX.XFRONT.XFE_E.HB.t4 5.6429
R7403 XRX.XFRONT.XFE_E.HB.n18 XRX.XFRONT.XFE_E.HB.n17 5.38537
R7404 XRX.XFRONT.XFE_E.HB.n22 XRX.XFRONT.XFE_E.HB.n21 5.38537
R7405 XRX.XFRONT.XFE_E.HB.n20 XRX.XFRONT.XFE_E.HB.n19 5.38537
R7406 XRX.XFRONT.XFE_E.HB.n26 XRX.XFRONT.XFE_E.HB.n25 5.32067
R7407 XRX.XFRONT.XFE_E.HB.n31 XRX.XFRONT.XFE_E.HB.n30 5.32067
R7408 XRX.XFRONT.XFE_E.HB.n2 XRX.XFRONT.XFE_E.HB.n1 4.42851
R7409 XRX.XFRONT.XFE_E.HB.n12 XRX.XFRONT.XFE_E.HB.n11 4.42851
R7410 XRX.XFRONT.XFE_E.HB.n7 XRX.XFRONT.XFE_E.HB.n6 4.42851
R7411 XRX.XFRONT.XFE_E.HB.n24 XRX.XFRONT.XFE_E.HB.n16 3.48311
R7412 XRX.XFRONT.XFE_E.HB.n33 XRX.XFRONT.XFE_E.HB.n29 2.34833
R7413 XRX.XFRONT.XFE_E.HB.n28 XRX.XFRONT.XFE_E.HB.n24 1.17441
R7414 XRX.XFRONT.XFE_E.HB XRX.XFRONT.XFE_E.HB.n34 1.13528
R7415 XRX.XFRONT.XFE_E.HB.n29 XRX.XFRONT.XFE_E.HB.n28 0.587457
R7416 XRX.XFRONT.XFE_E.HB.n25 XRX.XFRONT.XFE_E.HB.t2 0.228
R7417 XRX.XFRONT.XFE_E.HB.n25 XRX.XFRONT.XFE_E.HB.t3 0.228
R7418 XRX.XFRONT.XFE_E.HB.n30 XRX.XFRONT.XFE_E.HB.t5 0.228
R7419 XRX.XFRONT.XFE_E.HB.n30 XRX.XFRONT.XFE_E.HB.t16 0.228
R7420 XRX.XFRONT.XFE_E.HB.n17 XRX.XFRONT.XFE_E.HB.t12 0.20525
R7421 XRX.XFRONT.XFE_E.HB.n17 XRX.XFRONT.XFE_E.HB.t13 0.20525
R7422 XRX.XFRONT.XFE_E.HB.n21 XRX.XFRONT.XFE_E.HB.t10 0.20525
R7423 XRX.XFRONT.XFE_E.HB.n21 XRX.XFRONT.XFE_E.HB.t11 0.20525
R7424 XRX.XFRONT.XFE_E.HB.n19 XRX.XFRONT.XFE_E.HB.t8 0.20525
R7425 XRX.XFRONT.XFE_E.HB.n19 XRX.XFRONT.XFE_E.HB.t9 0.20525
R7426 XRX.XFRONT.XFE_E.HB.n22 XRX.XFRONT.XFE_E.HB.n20 0.189974
R7427 XRX.XFRONT.XFE_E.HB.n5 XRX.XFRONT.XFE_E.HB.n0 0.1205
R7428 XRX.XFRONT.XFE_E.HB.n23 XRX.XFRONT.XFE_E.HB.n22 0.0952368
R7429 XRX.XFRONT.XFE_E.HB.n23 XRX.XFRONT.XFE_E.HB.n18 0.0952368
R7430 XRX.XFRONT.XFE_E.HB.n27 XRX.XFRONT.XFE_E.HB.n26 0.0952368
R7431 XRX.XFRONT.XFE_E.HB.n15 XRX.XFRONT.XFE_E.HB.n14 0.0785
R7432 XRX.XFRONT.XFE_E.HB.n32 XRX.XFRONT.XFE_E.HB.n31 0.0241842
R7433 XRX.XFRONT.XFE_O.XP.t43 XRX.XFRONT.XFE_O.XP.n25 127.788
R7434 XRX.XFRONT.XFE_O.XP.t32 XRX.XFRONT.XFE_O.XP.n10 127.788
R7435 XRX.XFRONT.XFE_O.XP.t34 XRX.XFRONT.XFE_O.XP.n7 127.668
R7436 XRX.XFRONT.XFE_O.XP.n25 XRX.XFRONT.XFE_O.XP.t42 127.668
R7437 XRX.XFRONT.XFE_O.XP.n24 XRX.XFRONT.XFE_O.XP.t41 127.668
R7438 XRX.XFRONT.XFE_O.XP.n23 XRX.XFRONT.XFE_O.XP.t40 127.668
R7439 XRX.XFRONT.XFE_O.XP.n22 XRX.XFRONT.XFE_O.XP.t39 127.668
R7440 XRX.XFRONT.XFE_O.XP.n21 XRX.XFRONT.XFE_O.XP.t38 127.668
R7441 XRX.XFRONT.XFE_O.XP.n20 XRX.XFRONT.XFE_O.XP.t37 127.668
R7442 XRX.XFRONT.XFE_O.XP.t36 XRX.XFRONT.XFE_O.XP.n8 127.668
R7443 XRX.XFRONT.XFE_O.XP.n35 XRX.XFRONT.XFE_O.XP.t35 127.668
R7444 XRX.XFRONT.XFE_O.XP.n10 XRX.XFRONT.XFE_O.XP.t33 127.668
R7445 XRX.XFRONT.XFE_O.XP.n26 XRX.XFRONT.XFE_O.XP.t43 113.632
R7446 XRX.XFRONT.XFE_O.XP.n11 XRX.XFRONT.XFE_O.XP.t32 113.632
R7447 XRX.XFRONT.XFE_O.XP.n1 XRX.XFRONT.XFE_O.XP.t53 113.632
R7448 XRX.XFRONT.XFE_O.XP.n38 XRX.XFRONT.XFE_O.XP.t54 113.632
R7449 XRX.XFRONT.XFE_O.XP.n62 XRX.XFRONT.XFE_O.XP.t45 113.632
R7450 XRX.XFRONT.XFE_O.XP.n65 XRX.XFRONT.XFE_O.XP.t49 113.632
R7451 XRX.XFRONT.XFE_O.XP.n38 XRX.XFRONT.XFE_O.XP.t55 113.603
R7452 XRX.XFRONT.XFE_O.XP.n62 XRX.XFRONT.XFE_O.XP.t44 113.603
R7453 XRX.XFRONT.XFE_O.XP.n13 XRX.XFRONT.XFE_O.XP.t34 109.174
R7454 XRX.XFRONT.XFE_O.XP.t42 XRX.XFRONT.XFE_O.XP.n19 109.174
R7455 XRX.XFRONT.XFE_O.XP.n28 XRX.XFRONT.XFE_O.XP.t41 109.174
R7456 XRX.XFRONT.XFE_O.XP.n29 XRX.XFRONT.XFE_O.XP.t40 109.174
R7457 XRX.XFRONT.XFE_O.XP.n30 XRX.XFRONT.XFE_O.XP.t39 109.174
R7458 XRX.XFRONT.XFE_O.XP.n31 XRX.XFRONT.XFE_O.XP.t38 109.174
R7459 XRX.XFRONT.XFE_O.XP.n32 XRX.XFRONT.XFE_O.XP.t37 109.174
R7460 XRX.XFRONT.XFE_O.XP.n33 XRX.XFRONT.XFE_O.XP.t36 109.174
R7461 XRX.XFRONT.XFE_O.XP.t35 XRX.XFRONT.XFE_O.XP.n34 109.174
R7462 XRX.XFRONT.XFE_O.XP.t33 XRX.XFRONT.XFE_O.XP.n9 109.174
R7463 XRX.XFRONT.XFE_O.XP.n2 XRX.XFRONT.XFE_O.XP.t52 109.174
R7464 XRX.XFRONT.XFE_O.XP.n3 XRX.XFRONT.XFE_O.XP.t51 109.174
R7465 XRX.XFRONT.XFE_O.XP.n4 XRX.XFRONT.XFE_O.XP.t50 109.174
R7466 XRX.XFRONT.XFE_O.XP.n66 XRX.XFRONT.XFE_O.XP.t48 109.174
R7467 XRX.XFRONT.XFE_O.XP.n67 XRX.XFRONT.XFE_O.XP.t47 109.174
R7468 XRX.XFRONT.XFE_O.XP.n64 XRX.XFRONT.XFE_O.XP.t46 109.174
R7469 XRX.XFRONT.XFE_O.XP.n39 XRX.XFRONT.XFE_O.XP.n38 26.8696
R7470 XRX.XFRONT.XFE_O.XP.n63 XRX.XFRONT.XFE_O.XP.n62 22.8718
R7471 XRX.XFRONT.XFE_O.XP.n37 XRX.XFRONT.XFE_O.XP.n5 20.2802
R7472 XRX.XFRONT.XFE_O.XP.n69 XRX.XFRONT.XFE_O.XP.n64 18.5179
R7473 XRX.XFRONT.XFE_O.XP.n13 XRX.XFRONT.XFE_O.XP.n12 18.4942
R7474 XRX.XFRONT.XFE_O.XP.n28 XRX.XFRONT.XFE_O.XP.n27 18.4942
R7475 XRX.XFRONT.XFE_O.XP.n29 XRX.XFRONT.XFE_O.XP.n18 18.4942
R7476 XRX.XFRONT.XFE_O.XP.n30 XRX.XFRONT.XFE_O.XP.n17 18.4942
R7477 XRX.XFRONT.XFE_O.XP.n31 XRX.XFRONT.XFE_O.XP.n16 18.4942
R7478 XRX.XFRONT.XFE_O.XP.n32 XRX.XFRONT.XFE_O.XP.n15 18.4942
R7479 XRX.XFRONT.XFE_O.XP.n33 XRX.XFRONT.XFE_O.XP.n14 18.4942
R7480 XRX.XFRONT.XFE_O.XP.n34 XRX.XFRONT.XFE_O.XP.n6 18.4942
R7481 XRX.XFRONT.XFE_O.XP.n3 XRX.XFRONT.XFE_O.XP.n0 18.4942
R7482 XRX.XFRONT.XFE_O.XP.n5 XRX.XFRONT.XFE_O.XP.n4 18.4942
R7483 XRX.XFRONT.XFE_O.XP.n68 XRX.XFRONT.XFE_O.XP.n67 18.4942
R7484 XRX.XFRONT.XFE_O.XP.n49 XRX.XFRONT.XFE_O.XP.n48 16.6309
R7485 XRX.XFRONT.XFE_O.XP.n70 XRX.XFRONT.XFE_O.XP.n69 14.8896
R7486 XRX.XFRONT.XFE_O.XP.n80 XRX.XFRONT.XFE_O.XP.n79 14.2831
R7487 XRX.XFRONT.XFE_O.XP.n47 XRX.XFRONT.XFE_O.XP.n46 14.2831
R7488 XRX.XFRONT.XFE_O.XP.n61 XRX.XFRONT.XFE_O.XP.n60 11.7396
R7489 XRX.XFRONT.XFE_O.XP.n29 XRX.XFRONT.XFE_O.XP.n28 11.6805
R7490 XRX.XFRONT.XFE_O.XP.n28 XRX.XFRONT.XFE_O.XP.n19 11.6805
R7491 XRX.XFRONT.XFE_O.XP.n30 XRX.XFRONT.XFE_O.XP.n29 11.6805
R7492 XRX.XFRONT.XFE_O.XP.n31 XRX.XFRONT.XFE_O.XP.n30 11.6805
R7493 XRX.XFRONT.XFE_O.XP.n32 XRX.XFRONT.XFE_O.XP.n31 11.6805
R7494 XRX.XFRONT.XFE_O.XP.n33 XRX.XFRONT.XFE_O.XP.n32 11.6805
R7495 XRX.XFRONT.XFE_O.XP.n34 XRX.XFRONT.XFE_O.XP.n33 11.6805
R7496 XRX.XFRONT.XFE_O.XP.n34 XRX.XFRONT.XFE_O.XP.n13 11.6805
R7497 XRX.XFRONT.XFE_O.XP.n13 XRX.XFRONT.XFE_O.XP.n9 11.6805
R7498 XRX.XFRONT.XFE_O.XP.n3 XRX.XFRONT.XFE_O.XP.n2 11.6805
R7499 XRX.XFRONT.XFE_O.XP.n4 XRX.XFRONT.XFE_O.XP.n3 11.6805
R7500 XRX.XFRONT.XFE_O.XP.n67 XRX.XFRONT.XFE_O.XP.n66 11.6805
R7501 XRX.XFRONT.XFE_O.XP.n67 XRX.XFRONT.XFE_O.XP.n64 11.6805
R7502 XRX.XFRONT.XFE_O.XP.n36 XRX.XFRONT.XFE_O.XP.n6 10.8396
R7503 XRX.XFRONT.XFE_O.XP.n36 XRX.XFRONT.XFE_O.XP.n35 9.0005
R7504 XRX.XFRONT.XFE_O.XP.n27 XRX.XFRONT.XFE_O.XP.n26 7.17687
R7505 XRX.XFRONT.XFE_O.XP.n12 XRX.XFRONT.XFE_O.XP.n11 7.17687
R7506 XRX.XFRONT.XFE_O.XP.n1 XRX.XFRONT.XFE_O.XP.n0 7.17687
R7507 XRX.XFRONT.XFE_O.XP.n68 XRX.XFRONT.XFE_O.XP.n65 7.17687
R7508 XRX.XFRONT.XFE_O.XP.n37 XRX.XFRONT.XFE_O.XP.n36 6.94615
R7509 XRX.XFRONT.XFE_O.XP.n51 XRX.XFRONT.XFE_O.XP.t26 5.7796
R7510 XRX.XFRONT.XFE_O.XP.n57 XRX.XFRONT.XFE_O.XP.t31 5.7796
R7511 XRX.XFRONT.XFE_O.XP.n72 XRX.XFRONT.XFE_O.XP.t17 5.73764
R7512 XRX.XFRONT.XFE_O.XP.n41 XRX.XFRONT.XFE_O.XP.t20 5.73764
R7513 XRX.XFRONT.XFE_O.XP.n45 XRX.XFRONT.XFE_O.XP.t25 5.73764
R7514 XRX.XFRONT.XFE_O.XP.n48 XRX.XFRONT.XFE_O.XP.t30 5.66659
R7515 XRX.XFRONT.XFE_O.XP.n48 XRX.XFRONT.XFE_O.XP.t29 5.61922
R7516 XRX.XFRONT.XFE_O.XP.n79 XRX.XFRONT.XFE_O.XP.t8 5.57185
R7517 XRX.XFRONT.XFE_O.XP.n51 XRX.XFRONT.XFE_O.XP.n50 5.38537
R7518 XRX.XFRONT.XFE_O.XP.n53 XRX.XFRONT.XFE_O.XP.n52 5.38537
R7519 XRX.XFRONT.XFE_O.XP.n55 XRX.XFRONT.XFE_O.XP.n54 5.38537
R7520 XRX.XFRONT.XFE_O.XP.n59 XRX.XFRONT.XFE_O.XP.n58 5.38537
R7521 XRX.XFRONT.XFE_O.XP.n57 XRX.XFRONT.XFE_O.XP.n56 5.38537
R7522 XRX.XFRONT.XFE_O.XP.n41 XRX.XFRONT.XFE_O.XP.n40 5.32067
R7523 XRX.XFRONT.XFE_O.XP.n43 XRX.XFRONT.XFE_O.XP.n42 5.32067
R7524 XRX.XFRONT.XFE_O.XP.n45 XRX.XFRONT.XFE_O.XP.n44 5.32067
R7525 XRX.XFRONT.XFE_O.XP.n72 XRX.XFRONT.XFE_O.XP.n71 5.32067
R7526 XRX.XFRONT.XFE_O.XP.n74 XRX.XFRONT.XFE_O.XP.n73 5.32067
R7527 XRX.XFRONT.XFE_O.XP.n76 XRX.XFRONT.XFE_O.XP.n75 5.32067
R7528 XRX.XFRONT.XFE_O.XP.n78 XRX.XFRONT.XFE_O.XP.n77 5.32067
R7529 XRX.XFRONT.XFE_O.XP.n26 XRX.XFRONT.XFE_O.XP.n19 4.42851
R7530 XRX.XFRONT.XFE_O.XP.n11 XRX.XFRONT.XFE_O.XP.n9 4.42851
R7531 XRX.XFRONT.XFE_O.XP.n2 XRX.XFRONT.XFE_O.XP.n1 4.42851
R7532 XRX.XFRONT.XFE_O.XP.n66 XRX.XFRONT.XFE_O.XP.n65 4.42851
R7533 XRX.XFRONT.XFE_O.XP.n39 XRX.XFRONT.XFE_O.XP.n37 3.71789
R7534 XRX.XFRONT.XFE_O.XP.n61 XRX.XFRONT.XFE_O.XP.n49 3.13093
R7535 XRX.XFRONT.XFE_O.XP.n49 XRX.XFRONT.XFE_O.XP.n47 1.76137
R7536 XRX.XFRONT.XFE_O.XP.n47 XRX.XFRONT.XFE_O.XP.n39 1.72224
R7537 XRX.XFRONT.XFE_O.XP.n80 XRX.XFRONT.XFE_O.XP.n70 1.33093
R7538 XRX.XFRONT.XFE_O.XP.n63 XRX.XFRONT.XFE_O.XP.n61 1.01789
R7539 XRX.XFRONT.XFE_O.XP.n70 XRX.XFRONT.XFE_O.XP.n63 0.391804
R7540 XRX.XFRONT.XFE_O.XP.n40 XRX.XFRONT.XFE_O.XP.t18 0.228
R7541 XRX.XFRONT.XFE_O.XP.n40 XRX.XFRONT.XFE_O.XP.t19 0.228
R7542 XRX.XFRONT.XFE_O.XP.n42 XRX.XFRONT.XFE_O.XP.t23 0.228
R7543 XRX.XFRONT.XFE_O.XP.n42 XRX.XFRONT.XFE_O.XP.t24 0.228
R7544 XRX.XFRONT.XFE_O.XP.n44 XRX.XFRONT.XFE_O.XP.t21 0.228
R7545 XRX.XFRONT.XFE_O.XP.n44 XRX.XFRONT.XFE_O.XP.t22 0.228
R7546 XRX.XFRONT.XFE_O.XP.n71 XRX.XFRONT.XFE_O.XP.t15 0.228
R7547 XRX.XFRONT.XFE_O.XP.n71 XRX.XFRONT.XFE_O.XP.t16 0.228
R7548 XRX.XFRONT.XFE_O.XP.n73 XRX.XFRONT.XFE_O.XP.t13 0.228
R7549 XRX.XFRONT.XFE_O.XP.n73 XRX.XFRONT.XFE_O.XP.t14 0.228
R7550 XRX.XFRONT.XFE_O.XP.n75 XRX.XFRONT.XFE_O.XP.t11 0.228
R7551 XRX.XFRONT.XFE_O.XP.n75 XRX.XFRONT.XFE_O.XP.t12 0.228
R7552 XRX.XFRONT.XFE_O.XP.n77 XRX.XFRONT.XFE_O.XP.t9 0.228
R7553 XRX.XFRONT.XFE_O.XP.n77 XRX.XFRONT.XFE_O.XP.t10 0.228
R7554 XRX.XFRONT.XFE_O.XP.n50 XRX.XFRONT.XFE_O.XP.t28 0.20525
R7555 XRX.XFRONT.XFE_O.XP.n50 XRX.XFRONT.XFE_O.XP.t27 0.20525
R7556 XRX.XFRONT.XFE_O.XP.n52 XRX.XFRONT.XFE_O.XP.t5 0.20525
R7557 XRX.XFRONT.XFE_O.XP.n52 XRX.XFRONT.XFE_O.XP.t4 0.20525
R7558 XRX.XFRONT.XFE_O.XP.n54 XRX.XFRONT.XFE_O.XP.t7 0.20525
R7559 XRX.XFRONT.XFE_O.XP.n54 XRX.XFRONT.XFE_O.XP.t6 0.20525
R7560 XRX.XFRONT.XFE_O.XP.n58 XRX.XFRONT.XFE_O.XP.t1 0.20525
R7561 XRX.XFRONT.XFE_O.XP.n58 XRX.XFRONT.XFE_O.XP.t0 0.20525
R7562 XRX.XFRONT.XFE_O.XP.n56 XRX.XFRONT.XFE_O.XP.t3 0.20525
R7563 XRX.XFRONT.XFE_O.XP.n56 XRX.XFRONT.XFE_O.XP.t2 0.20525
R7564 XRX.XFRONT.XFE_O.XP.n78 XRX.XFRONT.XFE_O.XP.n76 0.189974
R7565 XRX.XFRONT.XFE_O.XP.n76 XRX.XFRONT.XFE_O.XP.n74 0.189974
R7566 XRX.XFRONT.XFE_O.XP.n74 XRX.XFRONT.XFE_O.XP.n72 0.189974
R7567 XRX.XFRONT.XFE_O.XP.n43 XRX.XFRONT.XFE_O.XP.n41 0.189974
R7568 XRX.XFRONT.XFE_O.XP.n59 XRX.XFRONT.XFE_O.XP.n57 0.189974
R7569 XRX.XFRONT.XFE_O.XP.n55 XRX.XFRONT.XFE_O.XP.n53 0.189974
R7570 XRX.XFRONT.XFE_O.XP.n53 XRX.XFRONT.XFE_O.XP.n51 0.189974
R7571 XRX.XFRONT.XFE_O.XP.n79 XRX.XFRONT.XFE_O.XP.n78 0.166289
R7572 XRX.XFRONT.XFE_O.XP.n10 XRX.XFRONT.XFE_O.XP.n7 0.1205
R7573 XRX.XFRONT.XFE_O.XP.n25 XRX.XFRONT.XFE_O.XP.n24 0.1205
R7574 XRX.XFRONT.XFE_O.XP.n24 XRX.XFRONT.XFE_O.XP.n23 0.1205
R7575 XRX.XFRONT.XFE_O.XP.n23 XRX.XFRONT.XFE_O.XP.n22 0.1205
R7576 XRX.XFRONT.XFE_O.XP.n22 XRX.XFRONT.XFE_O.XP.n21 0.1205
R7577 XRX.XFRONT.XFE_O.XP.n21 XRX.XFRONT.XFE_O.XP.n20 0.1205
R7578 XRX.XFRONT.XFE_O.XP.n20 XRX.XFRONT.XFE_O.XP.n8 0.1205
R7579 XRX.XFRONT.XFE_O.XP.n27 XRX.XFRONT.XFE_O.XP.n18 0.1205
R7580 XRX.XFRONT.XFE_O.XP.n18 XRX.XFRONT.XFE_O.XP.n17 0.1205
R7581 XRX.XFRONT.XFE_O.XP.n17 XRX.XFRONT.XFE_O.XP.n16 0.1205
R7582 XRX.XFRONT.XFE_O.XP.n16 XRX.XFRONT.XFE_O.XP.n15 0.1205
R7583 XRX.XFRONT.XFE_O.XP.n15 XRX.XFRONT.XFE_O.XP.n14 0.1205
R7584 XRX.XFRONT.XFE_O.XP.n5 XRX.XFRONT.XFE_O.XP.n0 0.1205
R7585 XRX.XFRONT.XFE_O.XP.n12 XRX.XFRONT.XFE_O.XP.n6 0.1085
R7586 XRX.XFRONT.XFE_O.XP.n35 XRX.XFRONT.XFE_O.XP.n7 0.1085
R7587 XRX.XFRONT.XFE_O.XP.n35 XRX.XFRONT.XFE_O.XP.n8 0.1085
R7588 XRX.XFRONT.XFE_O.XP.n14 XRX.XFRONT.XFE_O.XP.n6 0.1085
R7589 XRX.XFRONT.XFE_O.XP.n46 XRX.XFRONT.XFE_O.XP.n45 0.0952368
R7590 XRX.XFRONT.XFE_O.XP.n46 XRX.XFRONT.XFE_O.XP.n43 0.0952368
R7591 XRX.XFRONT.XFE_O.XP.n60 XRX.XFRONT.XFE_O.XP.n59 0.0952368
R7592 XRX.XFRONT.XFE_O.XP.n60 XRX.XFRONT.XFE_O.XP.n55 0.0952368
R7593 XRX.XFRONT.XFE_O.XP.n69 XRX.XFRONT.XFE_O.XP.n68 0.0785
R7594 XRX.XFRONT.XFE_O.XP XRX.XFRONT.XFE_O.XP.n80 0.0396304
R7595 XRX.XFRONT.XFE_O.XN.t43 XRX.XFRONT.XFE_O.XN.n60 127.788
R7596 XRX.XFRONT.XFE_O.XN.t32 XRX.XFRONT.XFE_O.XN.n45 127.788
R7597 XRX.XFRONT.XFE_O.XN.t34 XRX.XFRONT.XFE_O.XN.n42 127.668
R7598 XRX.XFRONT.XFE_O.XN.n60 XRX.XFRONT.XFE_O.XN.t42 127.668
R7599 XRX.XFRONT.XFE_O.XN.n59 XRX.XFRONT.XFE_O.XN.t41 127.668
R7600 XRX.XFRONT.XFE_O.XN.n58 XRX.XFRONT.XFE_O.XN.t40 127.668
R7601 XRX.XFRONT.XFE_O.XN.n57 XRX.XFRONT.XFE_O.XN.t39 127.668
R7602 XRX.XFRONT.XFE_O.XN.n56 XRX.XFRONT.XFE_O.XN.t38 127.668
R7603 XRX.XFRONT.XFE_O.XN.n55 XRX.XFRONT.XFE_O.XN.t37 127.668
R7604 XRX.XFRONT.XFE_O.XN.t36 XRX.XFRONT.XFE_O.XN.n43 127.668
R7605 XRX.XFRONT.XFE_O.XN.n70 XRX.XFRONT.XFE_O.XN.t35 127.668
R7606 XRX.XFRONT.XFE_O.XN.n45 XRX.XFRONT.XFE_O.XN.t33 127.668
R7607 XRX.XFRONT.XFE_O.XN.n16 XRX.XFRONT.XFE_O.XN.t44 113.632
R7608 XRX.XFRONT.XFE_O.XN.n10 XRX.XFRONT.XFE_O.XN.t46 113.632
R7609 XRX.XFRONT.XFE_O.XN.n61 XRX.XFRONT.XFE_O.XN.t43 113.632
R7610 XRX.XFRONT.XFE_O.XN.n46 XRX.XFRONT.XFE_O.XN.t32 113.632
R7611 XRX.XFRONT.XFE_O.XN.n39 XRX.XFRONT.XFE_O.XN.t51 113.632
R7612 XRX.XFRONT.XFE_O.XN.n74 XRX.XFRONT.XFE_O.XN.t55 113.632
R7613 XRX.XFRONT.XFE_O.XN.n16 XRX.XFRONT.XFE_O.XN.t45 113.603
R7614 XRX.XFRONT.XFE_O.XN.n39 XRX.XFRONT.XFE_O.XN.t50 113.603
R7615 XRX.XFRONT.XFE_O.XN.n12 XRX.XFRONT.XFE_O.XN.t48 109.174
R7616 XRX.XFRONT.XFE_O.XN.n13 XRX.XFRONT.XFE_O.XN.t49 109.174
R7617 XRX.XFRONT.XFE_O.XN.n11 XRX.XFRONT.XFE_O.XN.t47 109.174
R7618 XRX.XFRONT.XFE_O.XN.n48 XRX.XFRONT.XFE_O.XN.t34 109.174
R7619 XRX.XFRONT.XFE_O.XN.t42 XRX.XFRONT.XFE_O.XN.n54 109.174
R7620 XRX.XFRONT.XFE_O.XN.n63 XRX.XFRONT.XFE_O.XN.t41 109.174
R7621 XRX.XFRONT.XFE_O.XN.n64 XRX.XFRONT.XFE_O.XN.t40 109.174
R7622 XRX.XFRONT.XFE_O.XN.n65 XRX.XFRONT.XFE_O.XN.t39 109.174
R7623 XRX.XFRONT.XFE_O.XN.n66 XRX.XFRONT.XFE_O.XN.t38 109.174
R7624 XRX.XFRONT.XFE_O.XN.n67 XRX.XFRONT.XFE_O.XN.t37 109.174
R7625 XRX.XFRONT.XFE_O.XN.n68 XRX.XFRONT.XFE_O.XN.t36 109.174
R7626 XRX.XFRONT.XFE_O.XN.t35 XRX.XFRONT.XFE_O.XN.n69 109.174
R7627 XRX.XFRONT.XFE_O.XN.t33 XRX.XFRONT.XFE_O.XN.n44 109.174
R7628 XRX.XFRONT.XFE_O.XN.n75 XRX.XFRONT.XFE_O.XN.t54 109.174
R7629 XRX.XFRONT.XFE_O.XN.n76 XRX.XFRONT.XFE_O.XN.t53 109.174
R7630 XRX.XFRONT.XFE_O.XN.n73 XRX.XFRONT.XFE_O.XN.t52 109.174
R7631 XRX.XFRONT.XFE_O.XN.n40 XRX.XFRONT.XFE_O.XN.n39 26.5957
R7632 XRX.XFRONT.XFE_O.XN.n17 XRX.XFRONT.XFE_O.XN.n16 23.1457
R7633 XRX.XFRONT.XFE_O.XN.n79 XRX.XFRONT.XFE_O.XN.n78 19.3114
R7634 XRX.XFRONT.XFE_O.XN.n14 XRX.XFRONT.XFE_O.XN.n13 18.5179
R7635 XRX.XFRONT.XFE_O.XN.n78 XRX.XFRONT.XFE_O.XN.n73 18.5179
R7636 XRX.XFRONT.XFE_O.XN.n12 XRX.XFRONT.XFE_O.XN.n9 18.4942
R7637 XRX.XFRONT.XFE_O.XN.n48 XRX.XFRONT.XFE_O.XN.n47 18.4942
R7638 XRX.XFRONT.XFE_O.XN.n63 XRX.XFRONT.XFE_O.XN.n62 18.4942
R7639 XRX.XFRONT.XFE_O.XN.n64 XRX.XFRONT.XFE_O.XN.n53 18.4942
R7640 XRX.XFRONT.XFE_O.XN.n65 XRX.XFRONT.XFE_O.XN.n52 18.4942
R7641 XRX.XFRONT.XFE_O.XN.n66 XRX.XFRONT.XFE_O.XN.n51 18.4942
R7642 XRX.XFRONT.XFE_O.XN.n67 XRX.XFRONT.XFE_O.XN.n50 18.4942
R7643 XRX.XFRONT.XFE_O.XN.n68 XRX.XFRONT.XFE_O.XN.n49 18.4942
R7644 XRX.XFRONT.XFE_O.XN.n69 XRX.XFRONT.XFE_O.XN.n41 18.4942
R7645 XRX.XFRONT.XFE_O.XN.n77 XRX.XFRONT.XFE_O.XN.n76 18.4942
R7646 XRX.XFRONT.XFE_O.XN.n31 XRX.XFRONT.XFE_O.XN.n30 16.357
R7647 XRX.XFRONT.XFE_O.XN.n15 XRX.XFRONT.XFE_O.XN.n8 15.2222
R7648 XRX.XFRONT.XFE_O.XN.n15 XRX.XFRONT.XFE_O.XN.n14 14.6157
R7649 XRX.XFRONT.XFE_O.XN.n38 XRX.XFRONT.XFE_O.XN.n37 12.757
R7650 XRX.XFRONT.XFE_O.XN.n29 XRX.XFRONT.XFE_O.XN.n28 12.0135
R7651 XRX.XFRONT.XFE_O.XN.n12 XRX.XFRONT.XFE_O.XN.n11 11.6805
R7652 XRX.XFRONT.XFE_O.XN.n13 XRX.XFRONT.XFE_O.XN.n12 11.6805
R7653 XRX.XFRONT.XFE_O.XN.n64 XRX.XFRONT.XFE_O.XN.n63 11.6805
R7654 XRX.XFRONT.XFE_O.XN.n63 XRX.XFRONT.XFE_O.XN.n54 11.6805
R7655 XRX.XFRONT.XFE_O.XN.n65 XRX.XFRONT.XFE_O.XN.n64 11.6805
R7656 XRX.XFRONT.XFE_O.XN.n66 XRX.XFRONT.XFE_O.XN.n65 11.6805
R7657 XRX.XFRONT.XFE_O.XN.n67 XRX.XFRONT.XFE_O.XN.n66 11.6805
R7658 XRX.XFRONT.XFE_O.XN.n68 XRX.XFRONT.XFE_O.XN.n67 11.6805
R7659 XRX.XFRONT.XFE_O.XN.n69 XRX.XFRONT.XFE_O.XN.n68 11.6805
R7660 XRX.XFRONT.XFE_O.XN.n69 XRX.XFRONT.XFE_O.XN.n48 11.6805
R7661 XRX.XFRONT.XFE_O.XN.n48 XRX.XFRONT.XFE_O.XN.n44 11.6805
R7662 XRX.XFRONT.XFE_O.XN.n76 XRX.XFRONT.XFE_O.XN.n75 11.6805
R7663 XRX.XFRONT.XFE_O.XN.n76 XRX.XFRONT.XFE_O.XN.n73 11.6805
R7664 XRX.XFRONT.XFE_O.XN.n71 XRX.XFRONT.XFE_O.XN.n41 10.8396
R7665 XRX.XFRONT.XFE_O.XN.n71 XRX.XFRONT.XFE_O.XN.n70 9.0005
R7666 XRX.XFRONT.XFE_O.XN.n72 XRX.XFRONT.XFE_O.XN.n71 7.22007
R7667 XRX.XFRONT.XFE_O.XN.n10 XRX.XFRONT.XFE_O.XN.n9 7.17687
R7668 XRX.XFRONT.XFE_O.XN.n62 XRX.XFRONT.XFE_O.XN.n61 7.17687
R7669 XRX.XFRONT.XFE_O.XN.n47 XRX.XFRONT.XFE_O.XN.n46 7.17687
R7670 XRX.XFRONT.XFE_O.XN.n77 XRX.XFRONT.XFE_O.XN.n74 7.17687
R7671 XRX.XFRONT.XFE_O.XN.n19 XRX.XFRONT.XFE_O.XN.t13 5.7796
R7672 XRX.XFRONT.XFE_O.XN.n25 XRX.XFRONT.XFE_O.XN.t2 5.7796
R7673 XRX.XFRONT.XFE_O.XN.n1 XRX.XFRONT.XFE_O.XN.t22 5.73764
R7674 XRX.XFRONT.XFE_O.XN.n30 XRX.XFRONT.XFE_O.XN.t1 5.73764
R7675 XRX.XFRONT.XFE_O.XN.n8 XRX.XFRONT.XFE_O.XN.t31 5.6429
R7676 XRX.XFRONT.XFE_O.XN.n30 XRX.XFRONT.XFE_O.XN.t0 5.54817
R7677 XRX.XFRONT.XFE_O.XN.n37 XRX.XFRONT.XFE_O.XN.n32 5.51014
R7678 XRX.XFRONT.XFE_O.XN.n36 XRX.XFRONT.XFE_O.XN.n34 5.51014
R7679 XRX.XFRONT.XFE_O.XN.n19 XRX.XFRONT.XFE_O.XN.n18 5.38537
R7680 XRX.XFRONT.XFE_O.XN.n21 XRX.XFRONT.XFE_O.XN.n20 5.38537
R7681 XRX.XFRONT.XFE_O.XN.n23 XRX.XFRONT.XFE_O.XN.n22 5.38537
R7682 XRX.XFRONT.XFE_O.XN.n27 XRX.XFRONT.XFE_O.XN.n26 5.38537
R7683 XRX.XFRONT.XFE_O.XN.n25 XRX.XFRONT.XFE_O.XN.n24 5.38537
R7684 XRX.XFRONT.XFE_O.XN.n7 XRX.XFRONT.XFE_O.XN.n6 5.32067
R7685 XRX.XFRONT.XFE_O.XN.n5 XRX.XFRONT.XFE_O.XN.n4 5.32067
R7686 XRX.XFRONT.XFE_O.XN.n3 XRX.XFRONT.XFE_O.XN.n2 5.32067
R7687 XRX.XFRONT.XFE_O.XN.n1 XRX.XFRONT.XFE_O.XN.n0 5.32067
R7688 XRX.XFRONT.XFE_O.XN.n37 XRX.XFRONT.XFE_O.XN.n33 5.32067
R7689 XRX.XFRONT.XFE_O.XN.n36 XRX.XFRONT.XFE_O.XN.n35 5.32067
R7690 XRX.XFRONT.XFE_O.XN.n11 XRX.XFRONT.XFE_O.XN.n10 4.42851
R7691 XRX.XFRONT.XFE_O.XN.n61 XRX.XFRONT.XFE_O.XN.n54 4.42851
R7692 XRX.XFRONT.XFE_O.XN.n46 XRX.XFRONT.XFE_O.XN.n44 4.42851
R7693 XRX.XFRONT.XFE_O.XN.n75 XRX.XFRONT.XFE_O.XN.n74 4.42851
R7694 XRX.XFRONT.XFE_O.XN.n72 XRX.XFRONT.XFE_O.XN.n40 2.93528
R7695 XRX.XFRONT.XFE_O.XN.n31 XRX.XFRONT.XFE_O.XN.n29 2.93528
R7696 XRX.XFRONT.XFE_O.XN.n40 XRX.XFRONT.XFE_O.XN.n38 1.72224
R7697 XRX.XFRONT.XFE_O.XN.n38 XRX.XFRONT.XFE_O.XN.n31 1.64398
R7698 XRX.XFRONT.XFE_O.XN.n29 XRX.XFRONT.XFE_O.XN.n17 1.33093
R7699 XRX.XFRONT.XFE_O.XN.n79 XRX.XFRONT.XFE_O.XN.n72 0.783109
R7700 XRX.XFRONT.XFE_O.XN.n17 XRX.XFRONT.XFE_O.XN.n15 0.391804
R7701 XRX.XFRONT.XFE_O.XN.n6 XRX.XFRONT.XFE_O.XN.t29 0.228
R7702 XRX.XFRONT.XFE_O.XN.n6 XRX.XFRONT.XFE_O.XN.t30 0.228
R7703 XRX.XFRONT.XFE_O.XN.n4 XRX.XFRONT.XFE_O.XN.t27 0.228
R7704 XRX.XFRONT.XFE_O.XN.n4 XRX.XFRONT.XFE_O.XN.t28 0.228
R7705 XRX.XFRONT.XFE_O.XN.n2 XRX.XFRONT.XFE_O.XN.t25 0.228
R7706 XRX.XFRONT.XFE_O.XN.n2 XRX.XFRONT.XFE_O.XN.t26 0.228
R7707 XRX.XFRONT.XFE_O.XN.n0 XRX.XFRONT.XFE_O.XN.t23 0.228
R7708 XRX.XFRONT.XFE_O.XN.n0 XRX.XFRONT.XFE_O.XN.t24 0.228
R7709 XRX.XFRONT.XFE_O.XN.n32 XRX.XFRONT.XFE_O.XN.t20 0.228
R7710 XRX.XFRONT.XFE_O.XN.n32 XRX.XFRONT.XFE_O.XN.t21 0.228
R7711 XRX.XFRONT.XFE_O.XN.n33 XRX.XFRONT.XFE_O.XN.t18 0.228
R7712 XRX.XFRONT.XFE_O.XN.n33 XRX.XFRONT.XFE_O.XN.t19 0.228
R7713 XRX.XFRONT.XFE_O.XN.n35 XRX.XFRONT.XFE_O.XN.t16 0.228
R7714 XRX.XFRONT.XFE_O.XN.n35 XRX.XFRONT.XFE_O.XN.t17 0.228
R7715 XRX.XFRONT.XFE_O.XN.n34 XRX.XFRONT.XFE_O.XN.t14 0.228
R7716 XRX.XFRONT.XFE_O.XN.n34 XRX.XFRONT.XFE_O.XN.t15 0.228
R7717 XRX.XFRONT.XFE_O.XN.n18 XRX.XFRONT.XFE_O.XN.t11 0.20525
R7718 XRX.XFRONT.XFE_O.XN.n18 XRX.XFRONT.XFE_O.XN.t12 0.20525
R7719 XRX.XFRONT.XFE_O.XN.n20 XRX.XFRONT.XFE_O.XN.t9 0.20525
R7720 XRX.XFRONT.XFE_O.XN.n20 XRX.XFRONT.XFE_O.XN.t10 0.20525
R7721 XRX.XFRONT.XFE_O.XN.n22 XRX.XFRONT.XFE_O.XN.t7 0.20525
R7722 XRX.XFRONT.XFE_O.XN.n22 XRX.XFRONT.XFE_O.XN.t8 0.20525
R7723 XRX.XFRONT.XFE_O.XN.n26 XRX.XFRONT.XFE_O.XN.t5 0.20525
R7724 XRX.XFRONT.XFE_O.XN.n26 XRX.XFRONT.XFE_O.XN.t6 0.20525
R7725 XRX.XFRONT.XFE_O.XN.n24 XRX.XFRONT.XFE_O.XN.t3 0.20525
R7726 XRX.XFRONT.XFE_O.XN.n24 XRX.XFRONT.XFE_O.XN.t4 0.20525
R7727 XRX.XFRONT.XFE_O.XN.n27 XRX.XFRONT.XFE_O.XN.n25 0.189974
R7728 XRX.XFRONT.XFE_O.XN.n23 XRX.XFRONT.XFE_O.XN.n21 0.189974
R7729 XRX.XFRONT.XFE_O.XN.n21 XRX.XFRONT.XFE_O.XN.n19 0.189974
R7730 XRX.XFRONT.XFE_O.XN.n3 XRX.XFRONT.XFE_O.XN.n1 0.189974
R7731 XRX.XFRONT.XFE_O.XN.n5 XRX.XFRONT.XFE_O.XN.n3 0.189974
R7732 XRX.XFRONT.XFE_O.XN.n7 XRX.XFRONT.XFE_O.XN.n5 0.189974
R7733 XRX.XFRONT.XFE_O.XN.n37 XRX.XFRONT.XFE_O.XN.n36 0.189974
R7734 XRX.XFRONT.XFE_O.XN.n45 XRX.XFRONT.XFE_O.XN.n42 0.1205
R7735 XRX.XFRONT.XFE_O.XN.n60 XRX.XFRONT.XFE_O.XN.n59 0.1205
R7736 XRX.XFRONT.XFE_O.XN.n59 XRX.XFRONT.XFE_O.XN.n58 0.1205
R7737 XRX.XFRONT.XFE_O.XN.n58 XRX.XFRONT.XFE_O.XN.n57 0.1205
R7738 XRX.XFRONT.XFE_O.XN.n57 XRX.XFRONT.XFE_O.XN.n56 0.1205
R7739 XRX.XFRONT.XFE_O.XN.n56 XRX.XFRONT.XFE_O.XN.n55 0.1205
R7740 XRX.XFRONT.XFE_O.XN.n55 XRX.XFRONT.XFE_O.XN.n43 0.1205
R7741 XRX.XFRONT.XFE_O.XN.n62 XRX.XFRONT.XFE_O.XN.n53 0.1205
R7742 XRX.XFRONT.XFE_O.XN.n53 XRX.XFRONT.XFE_O.XN.n52 0.1205
R7743 XRX.XFRONT.XFE_O.XN.n52 XRX.XFRONT.XFE_O.XN.n51 0.1205
R7744 XRX.XFRONT.XFE_O.XN.n51 XRX.XFRONT.XFE_O.XN.n50 0.1205
R7745 XRX.XFRONT.XFE_O.XN.n50 XRX.XFRONT.XFE_O.XN.n49 0.1205
R7746 XRX.XFRONT.XFE_O.XN.n47 XRX.XFRONT.XFE_O.XN.n41 0.1085
R7747 XRX.XFRONT.XFE_O.XN.n70 XRX.XFRONT.XFE_O.XN.n42 0.1085
R7748 XRX.XFRONT.XFE_O.XN.n70 XRX.XFRONT.XFE_O.XN.n43 0.1085
R7749 XRX.XFRONT.XFE_O.XN.n49 XRX.XFRONT.XFE_O.XN.n41 0.1085
R7750 XRX.XFRONT.XFE_O.XN.n28 XRX.XFRONT.XFE_O.XN.n27 0.0952368
R7751 XRX.XFRONT.XFE_O.XN.n28 XRX.XFRONT.XFE_O.XN.n23 0.0952368
R7752 XRX.XFRONT.XFE_O.XN.n8 XRX.XFRONT.XFE_O.XN.n7 0.0952368
R7753 XRX.XFRONT.XFE_O.XN.n14 XRX.XFRONT.XFE_O.XN.n9 0.0785
R7754 XRX.XFRONT.XFE_O.XN.n78 XRX.XFRONT.XFE_O.XN.n77 0.0785
R7755 XRX.XFRONT.XFE_O.XN XRX.XFRONT.XFE_O.XN.n79 0.0396304
R7756 XRX.XFRONT.XFE_E.XN.t43 XRX.XFRONT.XFE_E.XN.n71 127.788
R7757 XRX.XFRONT.XFE_E.XN.t32 XRX.XFRONT.XFE_E.XN.n59 127.788
R7758 XRX.XFRONT.XFE_E.XN.t39 XRX.XFRONT.XFE_E.XN.n48 127.668
R7759 XRX.XFRONT.XFE_E.XN.n71 XRX.XFRONT.XFE_E.XN.t42 127.668
R7760 XRX.XFRONT.XFE_E.XN.t41 XRX.XFRONT.XFE_E.XN.n49 127.668
R7761 XRX.XFRONT.XFE_E.XN.n76 XRX.XFRONT.XFE_E.XN.t40 127.668
R7762 XRX.XFRONT.XFE_E.XN.n59 XRX.XFRONT.XFE_E.XN.t33 127.668
R7763 XRX.XFRONT.XFE_E.XN.n58 XRX.XFRONT.XFE_E.XN.t34 127.668
R7764 XRX.XFRONT.XFE_E.XN.n57 XRX.XFRONT.XFE_E.XN.t35 127.668
R7765 XRX.XFRONT.XFE_E.XN.n56 XRX.XFRONT.XFE_E.XN.t36 127.668
R7766 XRX.XFRONT.XFE_E.XN.n55 XRX.XFRONT.XFE_E.XN.t37 127.668
R7767 XRX.XFRONT.XFE_E.XN.n54 XRX.XFRONT.XFE_E.XN.t38 127.668
R7768 XRX.XFRONT.XFE_E.XN.n72 XRX.XFRONT.XFE_E.XN.t43 113.632
R7769 XRX.XFRONT.XFE_E.XN.n60 XRX.XFRONT.XFE_E.XN.t32 113.632
R7770 XRX.XFRONT.XFE_E.XN.n1 XRX.XFRONT.XFE_E.XN.t50 113.632
R7771 XRX.XFRONT.XFE_E.XN.n45 XRX.XFRONT.XFE_E.XN.t54 113.632
R7772 XRX.XFRONT.XFE_E.XN.n22 XRX.XFRONT.XFE_E.XN.t45 113.632
R7773 XRX.XFRONT.XFE_E.XN.n16 XRX.XFRONT.XFE_E.XN.t49 113.632
R7774 XRX.XFRONT.XFE_E.XN.n45 XRX.XFRONT.XFE_E.XN.t55 113.603
R7775 XRX.XFRONT.XFE_E.XN.n22 XRX.XFRONT.XFE_E.XN.t44 113.603
R7776 XRX.XFRONT.XFE_E.XN.n69 XRX.XFRONT.XFE_E.XN.t39 109.174
R7777 XRX.XFRONT.XFE_E.XN.t42 XRX.XFRONT.XFE_E.XN.n70 109.174
R7778 XRX.XFRONT.XFE_E.XN.n74 XRX.XFRONT.XFE_E.XN.t41 109.174
R7779 XRX.XFRONT.XFE_E.XN.t40 XRX.XFRONT.XFE_E.XN.n75 109.174
R7780 XRX.XFRONT.XFE_E.XN.n61 XRX.XFRONT.XFE_E.XN.t33 109.174
R7781 XRX.XFRONT.XFE_E.XN.n62 XRX.XFRONT.XFE_E.XN.t34 109.174
R7782 XRX.XFRONT.XFE_E.XN.n63 XRX.XFRONT.XFE_E.XN.t35 109.174
R7783 XRX.XFRONT.XFE_E.XN.n64 XRX.XFRONT.XFE_E.XN.t36 109.174
R7784 XRX.XFRONT.XFE_E.XN.n65 XRX.XFRONT.XFE_E.XN.t37 109.174
R7785 XRX.XFRONT.XFE_E.XN.t38 XRX.XFRONT.XFE_E.XN.n50 109.174
R7786 XRX.XFRONT.XFE_E.XN.n3 XRX.XFRONT.XFE_E.XN.t52 109.174
R7787 XRX.XFRONT.XFE_E.XN.n4 XRX.XFRONT.XFE_E.XN.t53 109.174
R7788 XRX.XFRONT.XFE_E.XN.n2 XRX.XFRONT.XFE_E.XN.t51 109.174
R7789 XRX.XFRONT.XFE_E.XN.n17 XRX.XFRONT.XFE_E.XN.t48 109.174
R7790 XRX.XFRONT.XFE_E.XN.n18 XRX.XFRONT.XFE_E.XN.t47 109.174
R7791 XRX.XFRONT.XFE_E.XN.n15 XRX.XFRONT.XFE_E.XN.t46 109.174
R7792 XRX.XFRONT.XFE_E.XN.n46 XRX.XFRONT.XFE_E.XN.n45 26.5957
R7793 XRX.XFRONT.XFE_E.XN.n23 XRX.XFRONT.XFE_E.XN.n22 23.1457
R7794 XRX.XFRONT.XFE_E.XN XRX.XFRONT.XFE_E.XN.n5 19.3505
R7795 XRX.XFRONT.XFE_E.XN.n5 XRX.XFRONT.XFE_E.XN.n4 18.5179
R7796 XRX.XFRONT.XFE_E.XN.n20 XRX.XFRONT.XFE_E.XN.n15 18.5179
R7797 XRX.XFRONT.XFE_E.XN.n69 XRX.XFRONT.XFE_E.XN.n68 18.4942
R7798 XRX.XFRONT.XFE_E.XN.n74 XRX.XFRONT.XFE_E.XN.n73 18.4942
R7799 XRX.XFRONT.XFE_E.XN.n75 XRX.XFRONT.XFE_E.XN.n47 18.4942
R7800 XRX.XFRONT.XFE_E.XN.n62 XRX.XFRONT.XFE_E.XN.n53 18.4942
R7801 XRX.XFRONT.XFE_E.XN.n63 XRX.XFRONT.XFE_E.XN.n52 18.4942
R7802 XRX.XFRONT.XFE_E.XN.n64 XRX.XFRONT.XFE_E.XN.n51 18.4942
R7803 XRX.XFRONT.XFE_E.XN.n66 XRX.XFRONT.XFE_E.XN.n65 18.4942
R7804 XRX.XFRONT.XFE_E.XN.n67 XRX.XFRONT.XFE_E.XN.n50 18.4942
R7805 XRX.XFRONT.XFE_E.XN.n3 XRX.XFRONT.XFE_E.XN.n0 18.4942
R7806 XRX.XFRONT.XFE_E.XN.n19 XRX.XFRONT.XFE_E.XN.n18 18.4942
R7807 XRX.XFRONT.XFE_E.XN.n37 XRX.XFRONT.XFE_E.XN.n36 16.357
R7808 XRX.XFRONT.XFE_E.XN.n21 XRX.XFRONT.XFE_E.XN.n14 15.2222
R7809 XRX.XFRONT.XFE_E.XN.n21 XRX.XFRONT.XFE_E.XN.n20 14.6157
R7810 XRX.XFRONT.XFE_E.XN.n44 XRX.XFRONT.XFE_E.XN.n43 12.757
R7811 XRX.XFRONT.XFE_E.XN.n35 XRX.XFRONT.XFE_E.XN.n34 12.0135
R7812 XRX.XFRONT.XFE_E.XN.n75 XRX.XFRONT.XFE_E.XN.n74 11.6805
R7813 XRX.XFRONT.XFE_E.XN.n74 XRX.XFRONT.XFE_E.XN.n70 11.6805
R7814 XRX.XFRONT.XFE_E.XN.n75 XRX.XFRONT.XFE_E.XN.n69 11.6805
R7815 XRX.XFRONT.XFE_E.XN.n62 XRX.XFRONT.XFE_E.XN.n61 11.6805
R7816 XRX.XFRONT.XFE_E.XN.n63 XRX.XFRONT.XFE_E.XN.n62 11.6805
R7817 XRX.XFRONT.XFE_E.XN.n64 XRX.XFRONT.XFE_E.XN.n63 11.6805
R7818 XRX.XFRONT.XFE_E.XN.n65 XRX.XFRONT.XFE_E.XN.n64 11.6805
R7819 XRX.XFRONT.XFE_E.XN.n65 XRX.XFRONT.XFE_E.XN.n50 11.6805
R7820 XRX.XFRONT.XFE_E.XN.n69 XRX.XFRONT.XFE_E.XN.n50 11.6805
R7821 XRX.XFRONT.XFE_E.XN.n3 XRX.XFRONT.XFE_E.XN.n2 11.6805
R7822 XRX.XFRONT.XFE_E.XN.n4 XRX.XFRONT.XFE_E.XN.n3 11.6805
R7823 XRX.XFRONT.XFE_E.XN.n18 XRX.XFRONT.XFE_E.XN.n17 11.6805
R7824 XRX.XFRONT.XFE_E.XN.n18 XRX.XFRONT.XFE_E.XN.n15 11.6805
R7825 XRX.XFRONT.XFE_E.XN.n77 XRX.XFRONT.XFE_E.XN.n47 10.8396
R7826 XRX.XFRONT.XFE_E.XN.n77 XRX.XFRONT.XFE_E.XN.n76 9.0005
R7827 XRX.XFRONT.XFE_E.XN.n78 XRX.XFRONT.XFE_E.XN.n77 7.22007
R7828 XRX.XFRONT.XFE_E.XN.n73 XRX.XFRONT.XFE_E.XN.n72 7.17687
R7829 XRX.XFRONT.XFE_E.XN.n60 XRX.XFRONT.XFE_E.XN.n53 7.17687
R7830 XRX.XFRONT.XFE_E.XN.n1 XRX.XFRONT.XFE_E.XN.n0 7.17687
R7831 XRX.XFRONT.XFE_E.XN.n19 XRX.XFRONT.XFE_E.XN.n16 7.17687
R7832 XRX.XFRONT.XFE_E.XN.n25 XRX.XFRONT.XFE_E.XN.t30 5.7796
R7833 XRX.XFRONT.XFE_E.XN.n29 XRX.XFRONT.XFE_E.XN.t8 5.7796
R7834 XRX.XFRONT.XFE_E.XN.n7 XRX.XFRONT.XFE_E.XN.t24 5.73764
R7835 XRX.XFRONT.XFE_E.XN.n36 XRX.XFRONT.XFE_E.XN.t1 5.73764
R7836 XRX.XFRONT.XFE_E.XN.n14 XRX.XFRONT.XFE_E.XN.t15 5.6429
R7837 XRX.XFRONT.XFE_E.XN.n36 XRX.XFRONT.XFE_E.XN.t0 5.54817
R7838 XRX.XFRONT.XFE_E.XN.n40 XRX.XFRONT.XFE_E.XN.n38 5.51014
R7839 XRX.XFRONT.XFE_E.XN.n43 XRX.XFRONT.XFE_E.XN.n42 5.51014
R7840 XRX.XFRONT.XFE_E.XN.n25 XRX.XFRONT.XFE_E.XN.n24 5.38537
R7841 XRX.XFRONT.XFE_E.XN.n27 XRX.XFRONT.XFE_E.XN.n26 5.38537
R7842 XRX.XFRONT.XFE_E.XN.n33 XRX.XFRONT.XFE_E.XN.n32 5.38537
R7843 XRX.XFRONT.XFE_E.XN.n31 XRX.XFRONT.XFE_E.XN.n30 5.38537
R7844 XRX.XFRONT.XFE_E.XN.n29 XRX.XFRONT.XFE_E.XN.n28 5.38537
R7845 XRX.XFRONT.XFE_E.XN.n40 XRX.XFRONT.XFE_E.XN.n39 5.32067
R7846 XRX.XFRONT.XFE_E.XN.n43 XRX.XFRONT.XFE_E.XN.n41 5.32067
R7847 XRX.XFRONT.XFE_E.XN.n7 XRX.XFRONT.XFE_E.XN.n6 5.32067
R7848 XRX.XFRONT.XFE_E.XN.n9 XRX.XFRONT.XFE_E.XN.n8 5.32067
R7849 XRX.XFRONT.XFE_E.XN.n11 XRX.XFRONT.XFE_E.XN.n10 5.32067
R7850 XRX.XFRONT.XFE_E.XN.n13 XRX.XFRONT.XFE_E.XN.n12 5.32067
R7851 XRX.XFRONT.XFE_E.XN.n72 XRX.XFRONT.XFE_E.XN.n70 4.42851
R7852 XRX.XFRONT.XFE_E.XN.n61 XRX.XFRONT.XFE_E.XN.n60 4.42851
R7853 XRX.XFRONT.XFE_E.XN.n2 XRX.XFRONT.XFE_E.XN.n1 4.42851
R7854 XRX.XFRONT.XFE_E.XN.n17 XRX.XFRONT.XFE_E.XN.n16 4.42851
R7855 XRX.XFRONT.XFE_E.XN.n37 XRX.XFRONT.XFE_E.XN.n35 2.93528
R7856 XRX.XFRONT.XFE_E.XN.n78 XRX.XFRONT.XFE_E.XN.n46 2.93528
R7857 XRX.XFRONT.XFE_E.XN.n46 XRX.XFRONT.XFE_E.XN.n44 1.72224
R7858 XRX.XFRONT.XFE_E.XN.n44 XRX.XFRONT.XFE_E.XN.n37 1.64398
R7859 XRX.XFRONT.XFE_E.XN.n35 XRX.XFRONT.XFE_E.XN.n23 1.33093
R7860 XRX.XFRONT.XFE_E.XN XRX.XFRONT.XFE_E.XN.n78 0.743978
R7861 XRX.XFRONT.XFE_E.XN.n23 XRX.XFRONT.XFE_E.XN.n21 0.391804
R7862 XRX.XFRONT.XFE_E.XN.n38 XRX.XFRONT.XFE_E.XN.t26 0.228
R7863 XRX.XFRONT.XFE_E.XN.n38 XRX.XFRONT.XFE_E.XN.t27 0.228
R7864 XRX.XFRONT.XFE_E.XN.n39 XRX.XFRONT.XFE_E.XN.t29 0.228
R7865 XRX.XFRONT.XFE_E.XN.n39 XRX.XFRONT.XFE_E.XN.t25 0.228
R7866 XRX.XFRONT.XFE_E.XN.n41 XRX.XFRONT.XFE_E.XN.t13 0.228
R7867 XRX.XFRONT.XFE_E.XN.n41 XRX.XFRONT.XFE_E.XN.t12 0.228
R7868 XRX.XFRONT.XFE_E.XN.n42 XRX.XFRONT.XFE_E.XN.t14 0.228
R7869 XRX.XFRONT.XFE_E.XN.n42 XRX.XFRONT.XFE_E.XN.t28 0.228
R7870 XRX.XFRONT.XFE_E.XN.n6 XRX.XFRONT.XFE_E.XN.t22 0.228
R7871 XRX.XFRONT.XFE_E.XN.n6 XRX.XFRONT.XFE_E.XN.t23 0.228
R7872 XRX.XFRONT.XFE_E.XN.n8 XRX.XFRONT.XFE_E.XN.t20 0.228
R7873 XRX.XFRONT.XFE_E.XN.n8 XRX.XFRONT.XFE_E.XN.t21 0.228
R7874 XRX.XFRONT.XFE_E.XN.n10 XRX.XFRONT.XFE_E.XN.t18 0.228
R7875 XRX.XFRONT.XFE_E.XN.n10 XRX.XFRONT.XFE_E.XN.t19 0.228
R7876 XRX.XFRONT.XFE_E.XN.n12 XRX.XFRONT.XFE_E.XN.t16 0.228
R7877 XRX.XFRONT.XFE_E.XN.n12 XRX.XFRONT.XFE_E.XN.t17 0.228
R7878 XRX.XFRONT.XFE_E.XN.n24 XRX.XFRONT.XFE_E.XN.t5 0.20525
R7879 XRX.XFRONT.XFE_E.XN.n24 XRX.XFRONT.XFE_E.XN.t31 0.20525
R7880 XRX.XFRONT.XFE_E.XN.n26 XRX.XFRONT.XFE_E.XN.t7 0.20525
R7881 XRX.XFRONT.XFE_E.XN.n26 XRX.XFRONT.XFE_E.XN.t6 0.20525
R7882 XRX.XFRONT.XFE_E.XN.n32 XRX.XFRONT.XFE_E.XN.t3 0.20525
R7883 XRX.XFRONT.XFE_E.XN.n32 XRX.XFRONT.XFE_E.XN.t2 0.20525
R7884 XRX.XFRONT.XFE_E.XN.n30 XRX.XFRONT.XFE_E.XN.t9 0.20525
R7885 XRX.XFRONT.XFE_E.XN.n30 XRX.XFRONT.XFE_E.XN.t4 0.20525
R7886 XRX.XFRONT.XFE_E.XN.n28 XRX.XFRONT.XFE_E.XN.t11 0.20525
R7887 XRX.XFRONT.XFE_E.XN.n28 XRX.XFRONT.XFE_E.XN.t10 0.20525
R7888 XRX.XFRONT.XFE_E.XN.n13 XRX.XFRONT.XFE_E.XN.n11 0.189974
R7889 XRX.XFRONT.XFE_E.XN.n11 XRX.XFRONT.XFE_E.XN.n9 0.189974
R7890 XRX.XFRONT.XFE_E.XN.n9 XRX.XFRONT.XFE_E.XN.n7 0.189974
R7891 XRX.XFRONT.XFE_E.XN.n43 XRX.XFRONT.XFE_E.XN.n40 0.189974
R7892 XRX.XFRONT.XFE_E.XN.n31 XRX.XFRONT.XFE_E.XN.n29 0.189974
R7893 XRX.XFRONT.XFE_E.XN.n33 XRX.XFRONT.XFE_E.XN.n31 0.189974
R7894 XRX.XFRONT.XFE_E.XN.n27 XRX.XFRONT.XFE_E.XN.n25 0.189974
R7895 XRX.XFRONT.XFE_E.XN.n68 XRX.XFRONT.XFE_E.XN.n67 0.1205
R7896 XRX.XFRONT.XFE_E.XN.n67 XRX.XFRONT.XFE_E.XN.n66 0.1205
R7897 XRX.XFRONT.XFE_E.XN.n66 XRX.XFRONT.XFE_E.XN.n51 0.1205
R7898 XRX.XFRONT.XFE_E.XN.n52 XRX.XFRONT.XFE_E.XN.n51 0.1205
R7899 XRX.XFRONT.XFE_E.XN.n53 XRX.XFRONT.XFE_E.XN.n52 0.1205
R7900 XRX.XFRONT.XFE_E.XN.n54 XRX.XFRONT.XFE_E.XN.n48 0.1205
R7901 XRX.XFRONT.XFE_E.XN.n55 XRX.XFRONT.XFE_E.XN.n54 0.1205
R7902 XRX.XFRONT.XFE_E.XN.n56 XRX.XFRONT.XFE_E.XN.n55 0.1205
R7903 XRX.XFRONT.XFE_E.XN.n57 XRX.XFRONT.XFE_E.XN.n56 0.1205
R7904 XRX.XFRONT.XFE_E.XN.n58 XRX.XFRONT.XFE_E.XN.n57 0.1205
R7905 XRX.XFRONT.XFE_E.XN.n59 XRX.XFRONT.XFE_E.XN.n58 0.1205
R7906 XRX.XFRONT.XFE_E.XN.n71 XRX.XFRONT.XFE_E.XN.n49 0.1205
R7907 XRX.XFRONT.XFE_E.XN.n68 XRX.XFRONT.XFE_E.XN.n47 0.1085
R7908 XRX.XFRONT.XFE_E.XN.n76 XRX.XFRONT.XFE_E.XN.n48 0.1085
R7909 XRX.XFRONT.XFE_E.XN.n76 XRX.XFRONT.XFE_E.XN.n49 0.1085
R7910 XRX.XFRONT.XFE_E.XN.n73 XRX.XFRONT.XFE_E.XN.n47 0.1085
R7911 XRX.XFRONT.XFE_E.XN.n14 XRX.XFRONT.XFE_E.XN.n13 0.0952368
R7912 XRX.XFRONT.XFE_E.XN.n34 XRX.XFRONT.XFE_E.XN.n33 0.0952368
R7913 XRX.XFRONT.XFE_E.XN.n34 XRX.XFRONT.XFE_E.XN.n27 0.0952368
R7914 XRX.XFRONT.XFE_E.XN.n5 XRX.XFRONT.XFE_E.XN.n0 0.0785
R7915 XRX.XFRONT.XFE_E.XN.n20 XRX.XFRONT.XFE_E.XN.n19 0.0785
R7916 XRX.XFRONT.XFE_E.XP.t43 XRX.XFRONT.XFE_E.XP.n39 127.788
R7917 XRX.XFRONT.XFE_E.XP.t32 XRX.XFRONT.XFE_E.XP.n27 127.788
R7918 XRX.XFRONT.XFE_E.XP.t39 XRX.XFRONT.XFE_E.XP.n16 127.668
R7919 XRX.XFRONT.XFE_E.XP.n39 XRX.XFRONT.XFE_E.XP.t42 127.668
R7920 XRX.XFRONT.XFE_E.XP.t41 XRX.XFRONT.XFE_E.XP.n17 127.668
R7921 XRX.XFRONT.XFE_E.XP.n44 XRX.XFRONT.XFE_E.XP.t40 127.668
R7922 XRX.XFRONT.XFE_E.XP.n27 XRX.XFRONT.XFE_E.XP.t33 127.668
R7923 XRX.XFRONT.XFE_E.XP.n26 XRX.XFRONT.XFE_E.XP.t34 127.668
R7924 XRX.XFRONT.XFE_E.XP.n25 XRX.XFRONT.XFE_E.XP.t35 127.668
R7925 XRX.XFRONT.XFE_E.XP.n24 XRX.XFRONT.XFE_E.XP.t36 127.668
R7926 XRX.XFRONT.XFE_E.XP.n23 XRX.XFRONT.XFE_E.XP.t37 127.668
R7927 XRX.XFRONT.XFE_E.XP.n22 XRX.XFRONT.XFE_E.XP.t38 127.668
R7928 XRX.XFRONT.XFE_E.XP.n71 XRX.XFRONT.XFE_E.XP.t44 113.632
R7929 XRX.XFRONT.XFE_E.XP.n74 XRX.XFRONT.XFE_E.XP.t46 113.632
R7930 XRX.XFRONT.XFE_E.XP.n40 XRX.XFRONT.XFE_E.XP.t43 113.632
R7931 XRX.XFRONT.XFE_E.XP.n28 XRX.XFRONT.XFE_E.XP.t32 113.632
R7932 XRX.XFRONT.XFE_E.XP.n47 XRX.XFRONT.XFE_E.XP.t51 113.632
R7933 XRX.XFRONT.XFE_E.XP.n10 XRX.XFRONT.XFE_E.XP.t52 113.632
R7934 XRX.XFRONT.XFE_E.XP.n71 XRX.XFRONT.XFE_E.XP.t45 113.603
R7935 XRX.XFRONT.XFE_E.XP.n47 XRX.XFRONT.XFE_E.XP.t50 113.603
R7936 XRX.XFRONT.XFE_E.XP.n76 XRX.XFRONT.XFE_E.XP.t48 109.174
R7937 XRX.XFRONT.XFE_E.XP.n77 XRX.XFRONT.XFE_E.XP.t49 109.174
R7938 XRX.XFRONT.XFE_E.XP.n75 XRX.XFRONT.XFE_E.XP.t47 109.174
R7939 XRX.XFRONT.XFE_E.XP.n37 XRX.XFRONT.XFE_E.XP.t39 109.174
R7940 XRX.XFRONT.XFE_E.XP.t42 XRX.XFRONT.XFE_E.XP.n38 109.174
R7941 XRX.XFRONT.XFE_E.XP.n42 XRX.XFRONT.XFE_E.XP.t41 109.174
R7942 XRX.XFRONT.XFE_E.XP.t40 XRX.XFRONT.XFE_E.XP.n43 109.174
R7943 XRX.XFRONT.XFE_E.XP.n29 XRX.XFRONT.XFE_E.XP.t33 109.174
R7944 XRX.XFRONT.XFE_E.XP.n30 XRX.XFRONT.XFE_E.XP.t34 109.174
R7945 XRX.XFRONT.XFE_E.XP.n31 XRX.XFRONT.XFE_E.XP.t35 109.174
R7946 XRX.XFRONT.XFE_E.XP.n32 XRX.XFRONT.XFE_E.XP.t36 109.174
R7947 XRX.XFRONT.XFE_E.XP.n33 XRX.XFRONT.XFE_E.XP.t37 109.174
R7948 XRX.XFRONT.XFE_E.XP.t38 XRX.XFRONT.XFE_E.XP.n18 109.174
R7949 XRX.XFRONT.XFE_E.XP.n13 XRX.XFRONT.XFE_E.XP.t55 109.174
R7950 XRX.XFRONT.XFE_E.XP.n12 XRX.XFRONT.XFE_E.XP.t54 109.174
R7951 XRX.XFRONT.XFE_E.XP.n11 XRX.XFRONT.XFE_E.XP.t53 109.174
R7952 XRX.XFRONT.XFE_E.XP.n48 XRX.XFRONT.XFE_E.XP.n47 26.8696
R7953 XRX.XFRONT.XFE_E.XP.n72 XRX.XFRONT.XFE_E.XP.n71 22.8718
R7954 XRX.XFRONT.XFE_E.XP.n46 XRX.XFRONT.XFE_E.XP.n14 20.2802
R7955 XRX.XFRONT.XFE_E.XP.n78 XRX.XFRONT.XFE_E.XP.n77 18.5179
R7956 XRX.XFRONT.XFE_E.XP.n76 XRX.XFRONT.XFE_E.XP.n73 18.4942
R7957 XRX.XFRONT.XFE_E.XP.n37 XRX.XFRONT.XFE_E.XP.n36 18.4942
R7958 XRX.XFRONT.XFE_E.XP.n42 XRX.XFRONT.XFE_E.XP.n41 18.4942
R7959 XRX.XFRONT.XFE_E.XP.n43 XRX.XFRONT.XFE_E.XP.n15 18.4942
R7960 XRX.XFRONT.XFE_E.XP.n30 XRX.XFRONT.XFE_E.XP.n21 18.4942
R7961 XRX.XFRONT.XFE_E.XP.n31 XRX.XFRONT.XFE_E.XP.n20 18.4942
R7962 XRX.XFRONT.XFE_E.XP.n32 XRX.XFRONT.XFE_E.XP.n19 18.4942
R7963 XRX.XFRONT.XFE_E.XP.n34 XRX.XFRONT.XFE_E.XP.n33 18.4942
R7964 XRX.XFRONT.XFE_E.XP.n35 XRX.XFRONT.XFE_E.XP.n18 18.4942
R7965 XRX.XFRONT.XFE_E.XP.n14 XRX.XFRONT.XFE_E.XP.n13 18.4942
R7966 XRX.XFRONT.XFE_E.XP.n12 XRX.XFRONT.XFE_E.XP.n9 18.4942
R7967 XRX.XFRONT.XFE_E.XP.n58 XRX.XFRONT.XFE_E.XP.n57 16.6309
R7968 XRX.XFRONT.XFE_E.XP.n79 XRX.XFRONT.XFE_E.XP.n78 14.8896
R7969 XRX.XFRONT.XFE_E.XP XRX.XFRONT.XFE_E.XP.n8 14.3222
R7970 XRX.XFRONT.XFE_E.XP.n56 XRX.XFRONT.XFE_E.XP.n55 14.2831
R7971 XRX.XFRONT.XFE_E.XP.n70 XRX.XFRONT.XFE_E.XP.n69 11.7396
R7972 XRX.XFRONT.XFE_E.XP.n76 XRX.XFRONT.XFE_E.XP.n75 11.6805
R7973 XRX.XFRONT.XFE_E.XP.n77 XRX.XFRONT.XFE_E.XP.n76 11.6805
R7974 XRX.XFRONT.XFE_E.XP.n43 XRX.XFRONT.XFE_E.XP.n42 11.6805
R7975 XRX.XFRONT.XFE_E.XP.n42 XRX.XFRONT.XFE_E.XP.n38 11.6805
R7976 XRX.XFRONT.XFE_E.XP.n43 XRX.XFRONT.XFE_E.XP.n37 11.6805
R7977 XRX.XFRONT.XFE_E.XP.n30 XRX.XFRONT.XFE_E.XP.n29 11.6805
R7978 XRX.XFRONT.XFE_E.XP.n31 XRX.XFRONT.XFE_E.XP.n30 11.6805
R7979 XRX.XFRONT.XFE_E.XP.n32 XRX.XFRONT.XFE_E.XP.n31 11.6805
R7980 XRX.XFRONT.XFE_E.XP.n33 XRX.XFRONT.XFE_E.XP.n32 11.6805
R7981 XRX.XFRONT.XFE_E.XP.n33 XRX.XFRONT.XFE_E.XP.n18 11.6805
R7982 XRX.XFRONT.XFE_E.XP.n37 XRX.XFRONT.XFE_E.XP.n18 11.6805
R7983 XRX.XFRONT.XFE_E.XP.n13 XRX.XFRONT.XFE_E.XP.n12 11.6805
R7984 XRX.XFRONT.XFE_E.XP.n12 XRX.XFRONT.XFE_E.XP.n11 11.6805
R7985 XRX.XFRONT.XFE_E.XP.n45 XRX.XFRONT.XFE_E.XP.n15 10.8396
R7986 XRX.XFRONT.XFE_E.XP.n45 XRX.XFRONT.XFE_E.XP.n44 9.0005
R7987 XRX.XFRONT.XFE_E.XP.n74 XRX.XFRONT.XFE_E.XP.n73 7.17687
R7988 XRX.XFRONT.XFE_E.XP.n41 XRX.XFRONT.XFE_E.XP.n40 7.17687
R7989 XRX.XFRONT.XFE_E.XP.n28 XRX.XFRONT.XFE_E.XP.n21 7.17687
R7990 XRX.XFRONT.XFE_E.XP.n10 XRX.XFRONT.XFE_E.XP.n9 7.17687
R7991 XRX.XFRONT.XFE_E.XP.n46 XRX.XFRONT.XFE_E.XP.n45 6.94615
R7992 XRX.XFRONT.XFE_E.XP.n60 XRX.XFRONT.XFE_E.XP.t13 5.7796
R7993 XRX.XFRONT.XFE_E.XP.n64 XRX.XFRONT.XFE_E.XP.t2 5.7796
R7994 XRX.XFRONT.XFE_E.XP.n1 XRX.XFRONT.XFE_E.XP.t22 5.73764
R7995 XRX.XFRONT.XFE_E.XP.n50 XRX.XFRONT.XFE_E.XP.t21 5.73764
R7996 XRX.XFRONT.XFE_E.XP.n52 XRX.XFRONT.XFE_E.XP.t14 5.73764
R7997 XRX.XFRONT.XFE_E.XP.n57 XRX.XFRONT.XFE_E.XP.t1 5.66659
R7998 XRX.XFRONT.XFE_E.XP.n57 XRX.XFRONT.XFE_E.XP.t0 5.61922
R7999 XRX.XFRONT.XFE_E.XP.n8 XRX.XFRONT.XFE_E.XP.t31 5.57185
R8000 XRX.XFRONT.XFE_E.XP.n60 XRX.XFRONT.XFE_E.XP.n59 5.38537
R8001 XRX.XFRONT.XFE_E.XP.n62 XRX.XFRONT.XFE_E.XP.n61 5.38537
R8002 XRX.XFRONT.XFE_E.XP.n68 XRX.XFRONT.XFE_E.XP.n67 5.38537
R8003 XRX.XFRONT.XFE_E.XP.n66 XRX.XFRONT.XFE_E.XP.n65 5.38537
R8004 XRX.XFRONT.XFE_E.XP.n64 XRX.XFRONT.XFE_E.XP.n63 5.38537
R8005 XRX.XFRONT.XFE_E.XP.n7 XRX.XFRONT.XFE_E.XP.n6 5.32067
R8006 XRX.XFRONT.XFE_E.XP.n5 XRX.XFRONT.XFE_E.XP.n4 5.32067
R8007 XRX.XFRONT.XFE_E.XP.n3 XRX.XFRONT.XFE_E.XP.n2 5.32067
R8008 XRX.XFRONT.XFE_E.XP.n1 XRX.XFRONT.XFE_E.XP.n0 5.32067
R8009 XRX.XFRONT.XFE_E.XP.n50 XRX.XFRONT.XFE_E.XP.n49 5.32067
R8010 XRX.XFRONT.XFE_E.XP.n54 XRX.XFRONT.XFE_E.XP.n53 5.32067
R8011 XRX.XFRONT.XFE_E.XP.n52 XRX.XFRONT.XFE_E.XP.n51 5.32067
R8012 XRX.XFRONT.XFE_E.XP.n75 XRX.XFRONT.XFE_E.XP.n74 4.42851
R8013 XRX.XFRONT.XFE_E.XP.n40 XRX.XFRONT.XFE_E.XP.n38 4.42851
R8014 XRX.XFRONT.XFE_E.XP.n29 XRX.XFRONT.XFE_E.XP.n28 4.42851
R8015 XRX.XFRONT.XFE_E.XP.n11 XRX.XFRONT.XFE_E.XP.n10 4.42851
R8016 XRX.XFRONT.XFE_E.XP.n48 XRX.XFRONT.XFE_E.XP.n46 3.71789
R8017 XRX.XFRONT.XFE_E.XP.n70 XRX.XFRONT.XFE_E.XP.n58 3.13093
R8018 XRX.XFRONT.XFE_E.XP.n58 XRX.XFRONT.XFE_E.XP.n56 1.76137
R8019 XRX.XFRONT.XFE_E.XP.n56 XRX.XFRONT.XFE_E.XP.n48 1.72224
R8020 XRX.XFRONT.XFE_E.XP XRX.XFRONT.XFE_E.XP.n79 1.2918
R8021 XRX.XFRONT.XFE_E.XP.n72 XRX.XFRONT.XFE_E.XP.n70 1.01789
R8022 XRX.XFRONT.XFE_E.XP.n79 XRX.XFRONT.XFE_E.XP.n72 0.391804
R8023 XRX.XFRONT.XFE_E.XP.n6 XRX.XFRONT.XFE_E.XP.t29 0.228
R8024 XRX.XFRONT.XFE_E.XP.n6 XRX.XFRONT.XFE_E.XP.t30 0.228
R8025 XRX.XFRONT.XFE_E.XP.n4 XRX.XFRONT.XFE_E.XP.t27 0.228
R8026 XRX.XFRONT.XFE_E.XP.n4 XRX.XFRONT.XFE_E.XP.t28 0.228
R8027 XRX.XFRONT.XFE_E.XP.n2 XRX.XFRONT.XFE_E.XP.t25 0.228
R8028 XRX.XFRONT.XFE_E.XP.n2 XRX.XFRONT.XFE_E.XP.t26 0.228
R8029 XRX.XFRONT.XFE_E.XP.n0 XRX.XFRONT.XFE_E.XP.t23 0.228
R8030 XRX.XFRONT.XFE_E.XP.n0 XRX.XFRONT.XFE_E.XP.t24 0.228
R8031 XRX.XFRONT.XFE_E.XP.n49 XRX.XFRONT.XFE_E.XP.t19 0.228
R8032 XRX.XFRONT.XFE_E.XP.n49 XRX.XFRONT.XFE_E.XP.t20 0.228
R8033 XRX.XFRONT.XFE_E.XP.n53 XRX.XFRONT.XFE_E.XP.t17 0.228
R8034 XRX.XFRONT.XFE_E.XP.n53 XRX.XFRONT.XFE_E.XP.t18 0.228
R8035 XRX.XFRONT.XFE_E.XP.n51 XRX.XFRONT.XFE_E.XP.t15 0.228
R8036 XRX.XFRONT.XFE_E.XP.n51 XRX.XFRONT.XFE_E.XP.t16 0.228
R8037 XRX.XFRONT.XFE_E.XP.n59 XRX.XFRONT.XFE_E.XP.t11 0.20525
R8038 XRX.XFRONT.XFE_E.XP.n59 XRX.XFRONT.XFE_E.XP.t12 0.20525
R8039 XRX.XFRONT.XFE_E.XP.n61 XRX.XFRONT.XFE_E.XP.t9 0.20525
R8040 XRX.XFRONT.XFE_E.XP.n61 XRX.XFRONT.XFE_E.XP.t10 0.20525
R8041 XRX.XFRONT.XFE_E.XP.n67 XRX.XFRONT.XFE_E.XP.t7 0.20525
R8042 XRX.XFRONT.XFE_E.XP.n67 XRX.XFRONT.XFE_E.XP.t8 0.20525
R8043 XRX.XFRONT.XFE_E.XP.n65 XRX.XFRONT.XFE_E.XP.t5 0.20525
R8044 XRX.XFRONT.XFE_E.XP.n65 XRX.XFRONT.XFE_E.XP.t6 0.20525
R8045 XRX.XFRONT.XFE_E.XP.n63 XRX.XFRONT.XFE_E.XP.t3 0.20525
R8046 XRX.XFRONT.XFE_E.XP.n63 XRX.XFRONT.XFE_E.XP.t4 0.20525
R8047 XRX.XFRONT.XFE_E.XP.n66 XRX.XFRONT.XFE_E.XP.n64 0.189974
R8048 XRX.XFRONT.XFE_E.XP.n68 XRX.XFRONT.XFE_E.XP.n66 0.189974
R8049 XRX.XFRONT.XFE_E.XP.n62 XRX.XFRONT.XFE_E.XP.n60 0.189974
R8050 XRX.XFRONT.XFE_E.XP.n3 XRX.XFRONT.XFE_E.XP.n1 0.189974
R8051 XRX.XFRONT.XFE_E.XP.n5 XRX.XFRONT.XFE_E.XP.n3 0.189974
R8052 XRX.XFRONT.XFE_E.XP.n7 XRX.XFRONT.XFE_E.XP.n5 0.189974
R8053 XRX.XFRONT.XFE_E.XP.n54 XRX.XFRONT.XFE_E.XP.n52 0.189974
R8054 XRX.XFRONT.XFE_E.XP.n8 XRX.XFRONT.XFE_E.XP.n7 0.166289
R8055 XRX.XFRONT.XFE_E.XP.n36 XRX.XFRONT.XFE_E.XP.n35 0.1205
R8056 XRX.XFRONT.XFE_E.XP.n35 XRX.XFRONT.XFE_E.XP.n34 0.1205
R8057 XRX.XFRONT.XFE_E.XP.n34 XRX.XFRONT.XFE_E.XP.n19 0.1205
R8058 XRX.XFRONT.XFE_E.XP.n20 XRX.XFRONT.XFE_E.XP.n19 0.1205
R8059 XRX.XFRONT.XFE_E.XP.n21 XRX.XFRONT.XFE_E.XP.n20 0.1205
R8060 XRX.XFRONT.XFE_E.XP.n22 XRX.XFRONT.XFE_E.XP.n16 0.1205
R8061 XRX.XFRONT.XFE_E.XP.n23 XRX.XFRONT.XFE_E.XP.n22 0.1205
R8062 XRX.XFRONT.XFE_E.XP.n24 XRX.XFRONT.XFE_E.XP.n23 0.1205
R8063 XRX.XFRONT.XFE_E.XP.n25 XRX.XFRONT.XFE_E.XP.n24 0.1205
R8064 XRX.XFRONT.XFE_E.XP.n26 XRX.XFRONT.XFE_E.XP.n25 0.1205
R8065 XRX.XFRONT.XFE_E.XP.n27 XRX.XFRONT.XFE_E.XP.n26 0.1205
R8066 XRX.XFRONT.XFE_E.XP.n39 XRX.XFRONT.XFE_E.XP.n17 0.1205
R8067 XRX.XFRONT.XFE_E.XP.n14 XRX.XFRONT.XFE_E.XP.n9 0.1205
R8068 XRX.XFRONT.XFE_E.XP.n36 XRX.XFRONT.XFE_E.XP.n15 0.1085
R8069 XRX.XFRONT.XFE_E.XP.n44 XRX.XFRONT.XFE_E.XP.n16 0.1085
R8070 XRX.XFRONT.XFE_E.XP.n44 XRX.XFRONT.XFE_E.XP.n17 0.1085
R8071 XRX.XFRONT.XFE_E.XP.n41 XRX.XFRONT.XFE_E.XP.n15 0.1085
R8072 XRX.XFRONT.XFE_E.XP.n69 XRX.XFRONT.XFE_E.XP.n68 0.0952368
R8073 XRX.XFRONT.XFE_E.XP.n69 XRX.XFRONT.XFE_E.XP.n62 0.0952368
R8074 XRX.XFRONT.XFE_E.XP.n55 XRX.XFRONT.XFE_E.XP.n54 0.0952368
R8075 XRX.XFRONT.XFE_E.XP.n55 XRX.XFRONT.XFE_E.XP.n50 0.0952368
R8076 XRX.XFRONT.XFE_E.XP.n78 XRX.XFRONT.XFE_E.XP.n73 0.0785
R8077 XRX.XCAP.O_RST_TAIL.n10 XRX.XCAP.O_RST_TAIL.n2 15.9369
R8078 XRX.XCAP.O_RST_TAIL.n10 XRX.XCAP.O_RST_TAIL.n9 10.957
R8079 XRX.XCAP.O_RST_TAIL.n4 XRX.XCAP.O_RST_TAIL.t11 5.7796
R8080 XRX.XCAP.O_RST_TAIL.n9 XRX.XCAP.O_RST_TAIL.t4 5.68486
R8081 XRX.XCAP.O_RST_TAIL.n2 XRX.XCAP.O_RST_TAIL.n0 5.57485
R8082 XRX.XCAP.O_RST_TAIL.n4 XRX.XCAP.O_RST_TAIL.n3 5.38537
R8083 XRX.XCAP.O_RST_TAIL.n2 XRX.XCAP.O_RST_TAIL.n1 5.38537
R8084 XRX.XCAP.O_RST_TAIL.n6 XRX.XCAP.O_RST_TAIL.n5 5.38537
R8085 XRX.XCAP.O_RST_TAIL.n8 XRX.XCAP.O_RST_TAIL.n7 5.38537
R8086 XRX.XCAP.O_RST_TAIL.n3 XRX.XCAP.O_RST_TAIL.t9 0.20525
R8087 XRX.XCAP.O_RST_TAIL.n3 XRX.XCAP.O_RST_TAIL.t10 0.20525
R8088 XRX.XCAP.O_RST_TAIL.n1 XRX.XCAP.O_RST_TAIL.t1 0.20525
R8089 XRX.XCAP.O_RST_TAIL.n1 XRX.XCAP.O_RST_TAIL.t0 0.20525
R8090 XRX.XCAP.O_RST_TAIL.n0 XRX.XCAP.O_RST_TAIL.t3 0.20525
R8091 XRX.XCAP.O_RST_TAIL.n0 XRX.XCAP.O_RST_TAIL.t2 0.20525
R8092 XRX.XCAP.O_RST_TAIL.n5 XRX.XCAP.O_RST_TAIL.t7 0.20525
R8093 XRX.XCAP.O_RST_TAIL.n5 XRX.XCAP.O_RST_TAIL.t8 0.20525
R8094 XRX.XCAP.O_RST_TAIL.n7 XRX.XCAP.O_RST_TAIL.t5 0.20525
R8095 XRX.XCAP.O_RST_TAIL.n7 XRX.XCAP.O_RST_TAIL.t6 0.20525
R8096 XRX.XCAP.O_RST_TAIL.n8 XRX.XCAP.O_RST_TAIL.n6 0.189974
R8097 XRX.XCAP.O_RST_TAIL.n6 XRX.XCAP.O_RST_TAIL.n4 0.189974
R8098 XRX.XCAP.O_RST_TAIL.n9 XRX.XCAP.O_RST_TAIL.n8 0.0952368
R8099 XRX.XCAP.O_RST_TAIL XRX.XCAP.O_RST_TAIL.n10 0.0396304
R8100 XRX.XCAP.E_RST_TAIL.n10 XRX.XCAP.E_RST_TAIL.n9 11.9456
R8101 XRX.XCAP.E_RST_TAIL.n10 XRX.XCAP.E_RST_TAIL.n6 11.6614
R8102 XRX.XCAP.E_RST_TAIL.n1 XRX.XCAP.E_RST_TAIL.t8 5.7796
R8103 XRX.XCAP.E_RST_TAIL.n6 XRX.XCAP.E_RST_TAIL.t1 5.68486
R8104 XRX.XCAP.E_RST_TAIL.n9 XRX.XCAP.E_RST_TAIL.n7 5.57485
R8105 XRX.XCAP.E_RST_TAIL.n9 XRX.XCAP.E_RST_TAIL.n8 5.38537
R8106 XRX.XCAP.E_RST_TAIL.n1 XRX.XCAP.E_RST_TAIL.n0 5.38537
R8107 XRX.XCAP.E_RST_TAIL.n3 XRX.XCAP.E_RST_TAIL.n2 5.38537
R8108 XRX.XCAP.E_RST_TAIL.n5 XRX.XCAP.E_RST_TAIL.n4 5.38537
R8109 XRX.XCAP.E_RST_TAIL.n8 XRX.XCAP.E_RST_TAIL.t9 0.20525
R8110 XRX.XCAP.E_RST_TAIL.n8 XRX.XCAP.E_RST_TAIL.t0 0.20525
R8111 XRX.XCAP.E_RST_TAIL.n7 XRX.XCAP.E_RST_TAIL.t11 0.20525
R8112 XRX.XCAP.E_RST_TAIL.n7 XRX.XCAP.E_RST_TAIL.t10 0.20525
R8113 XRX.XCAP.E_RST_TAIL.n0 XRX.XCAP.E_RST_TAIL.t6 0.20525
R8114 XRX.XCAP.E_RST_TAIL.n0 XRX.XCAP.E_RST_TAIL.t7 0.20525
R8115 XRX.XCAP.E_RST_TAIL.n2 XRX.XCAP.E_RST_TAIL.t4 0.20525
R8116 XRX.XCAP.E_RST_TAIL.n2 XRX.XCAP.E_RST_TAIL.t5 0.20525
R8117 XRX.XCAP.E_RST_TAIL.n4 XRX.XCAP.E_RST_TAIL.t2 0.20525
R8118 XRX.XCAP.E_RST_TAIL.n4 XRX.XCAP.E_RST_TAIL.t3 0.20525
R8119 XRX.XCAP.E_RST_TAIL.n5 XRX.XCAP.E_RST_TAIL.n3 0.189974
R8120 XRX.XCAP.E_RST_TAIL.n3 XRX.XCAP.E_RST_TAIL.n1 0.189974
R8121 XRX.XCAP.E_RST_TAIL.n6 XRX.XCAP.E_RST_TAIL.n5 0.0952368
R8122 XRX.XCAP.E_RST_TAIL XRX.XCAP.E_RST_TAIL.n10 0.0396304
R8123 XRX.XCAP.O_SET_TAIL.n9 XRX.XCAP.O_SET_TAIL.n5 11.3875
R8124 XRX.XCAP.O_SET_TAIL.n9 XRX.XCAP.O_SET_TAIL.n8 9.68219
R8125 XRX.XCAP.O_SET_TAIL.n1 XRX.XCAP.O_SET_TAIL.t10 5.7796
R8126 XRX.XCAP.O_SET_TAIL.n5 XRX.XCAP.O_SET_TAIL.t3 5.7796
R8127 XRX.XCAP.O_SET_TAIL.n8 XRX.XCAP.O_SET_TAIL.n6 5.57485
R8128 XRX.XCAP.O_SET_TAIL.n1 XRX.XCAP.O_SET_TAIL.n0 5.38537
R8129 XRX.XCAP.O_SET_TAIL.n3 XRX.XCAP.O_SET_TAIL.n2 5.38537
R8130 XRX.XCAP.O_SET_TAIL.n8 XRX.XCAP.O_SET_TAIL.n7 5.38537
R8131 XRX.XCAP.O_SET_TAIL.n5 XRX.XCAP.O_SET_TAIL.n4 5.38537
R8132 XRX.XCAP.O_SET_TAIL.n0 XRX.XCAP.O_SET_TAIL.t8 0.20525
R8133 XRX.XCAP.O_SET_TAIL.n0 XRX.XCAP.O_SET_TAIL.t9 0.20525
R8134 XRX.XCAP.O_SET_TAIL.n2 XRX.XCAP.O_SET_TAIL.t6 0.20525
R8135 XRX.XCAP.O_SET_TAIL.n2 XRX.XCAP.O_SET_TAIL.t7 0.20525
R8136 XRX.XCAP.O_SET_TAIL.n7 XRX.XCAP.O_SET_TAIL.t1 0.20525
R8137 XRX.XCAP.O_SET_TAIL.n7 XRX.XCAP.O_SET_TAIL.t11 0.20525
R8138 XRX.XCAP.O_SET_TAIL.n6 XRX.XCAP.O_SET_TAIL.t0 0.20525
R8139 XRX.XCAP.O_SET_TAIL.n6 XRX.XCAP.O_SET_TAIL.t2 0.20525
R8140 XRX.XCAP.O_SET_TAIL.n4 XRX.XCAP.O_SET_TAIL.t4 0.20525
R8141 XRX.XCAP.O_SET_TAIL.n4 XRX.XCAP.O_SET_TAIL.t5 0.20525
R8142 XRX.XCAP.O_SET_TAIL.n5 XRX.XCAP.O_SET_TAIL.n3 0.189974
R8143 XRX.XCAP.O_SET_TAIL.n3 XRX.XCAP.O_SET_TAIL.n1 0.189974
R8144 XRX.XCAP.O_SET_TAIL XRX.XCAP.O_SET_TAIL.n9 0.0396304
R8145 XRX.XCAP.E_SET_TAIL.n9 XRX.XCAP.E_SET_TAIL.n2 12.1083
R8146 XRX.XCAP.E_SET_TAIL.n9 XRX.XCAP.E_SET_TAIL.n8 10.2135
R8147 XRX.XCAP.E_SET_TAIL.n4 XRX.XCAP.E_SET_TAIL.t7 5.7796
R8148 XRX.XCAP.E_SET_TAIL.n8 XRX.XCAP.E_SET_TAIL.t0 5.7796
R8149 XRX.XCAP.E_SET_TAIL.n2 XRX.XCAP.E_SET_TAIL.n0 5.57485
R8150 XRX.XCAP.E_SET_TAIL.n4 XRX.XCAP.E_SET_TAIL.n3 5.38537
R8151 XRX.XCAP.E_SET_TAIL.n6 XRX.XCAP.E_SET_TAIL.n5 5.38537
R8152 XRX.XCAP.E_SET_TAIL.n2 XRX.XCAP.E_SET_TAIL.n1 5.38537
R8153 XRX.XCAP.E_SET_TAIL.n8 XRX.XCAP.E_SET_TAIL.n7 5.38537
R8154 XRX.XCAP.E_SET_TAIL.n3 XRX.XCAP.E_SET_TAIL.t5 0.20525
R8155 XRX.XCAP.E_SET_TAIL.n3 XRX.XCAP.E_SET_TAIL.t6 0.20525
R8156 XRX.XCAP.E_SET_TAIL.n5 XRX.XCAP.E_SET_TAIL.t3 0.20525
R8157 XRX.XCAP.E_SET_TAIL.n5 XRX.XCAP.E_SET_TAIL.t4 0.20525
R8158 XRX.XCAP.E_SET_TAIL.n1 XRX.XCAP.E_SET_TAIL.t10 0.20525
R8159 XRX.XCAP.E_SET_TAIL.n1 XRX.XCAP.E_SET_TAIL.t8 0.20525
R8160 XRX.XCAP.E_SET_TAIL.n0 XRX.XCAP.E_SET_TAIL.t9 0.20525
R8161 XRX.XCAP.E_SET_TAIL.n0 XRX.XCAP.E_SET_TAIL.t11 0.20525
R8162 XRX.XCAP.E_SET_TAIL.n7 XRX.XCAP.E_SET_TAIL.t1 0.20525
R8163 XRX.XCAP.E_SET_TAIL.n7 XRX.XCAP.E_SET_TAIL.t2 0.20525
R8164 XRX.XCAP.E_SET_TAIL.n8 XRX.XCAP.E_SET_TAIL.n6 0.189974
R8165 XRX.XCAP.E_SET_TAIL.n6 XRX.XCAP.E_SET_TAIL.n4 0.189974
R8166 XRX.XCAP.E_SET_TAIL XRX.XCAP.E_SET_TAIL.n9 0.0396304
R8167 XRX.XCAP.O_PSET_TAIL.n10 XRX.XCAP.O_PSET_TAIL.n2 15.7351
R8168 XRX.XCAP.O_PSET_TAIL.n10 XRX.XCAP.O_PSET_TAIL.n9 12.6005
R8169 XRX.XCAP.O_PSET_TAIL.n4 XRX.XCAP.O_PSET_TAIL.t11 5.73764
R8170 XRX.XCAP.O_PSET_TAIL.n9 XRX.XCAP.O_PSET_TAIL.t4 5.54817
R8171 XRX.XCAP.O_PSET_TAIL.n2 XRX.XCAP.O_PSET_TAIL.n0 5.51014
R8172 XRX.XCAP.O_PSET_TAIL.n4 XRX.XCAP.O_PSET_TAIL.n3 5.32067
R8173 XRX.XCAP.O_PSET_TAIL.n6 XRX.XCAP.O_PSET_TAIL.n5 5.32067
R8174 XRX.XCAP.O_PSET_TAIL.n8 XRX.XCAP.O_PSET_TAIL.n7 5.32067
R8175 XRX.XCAP.O_PSET_TAIL.n2 XRX.XCAP.O_PSET_TAIL.n1 5.32067
R8176 XRX.XCAP.O_PSET_TAIL.n3 XRX.XCAP.O_PSET_TAIL.t9 0.228
R8177 XRX.XCAP.O_PSET_TAIL.n3 XRX.XCAP.O_PSET_TAIL.t10 0.228
R8178 XRX.XCAP.O_PSET_TAIL.n5 XRX.XCAP.O_PSET_TAIL.t7 0.228
R8179 XRX.XCAP.O_PSET_TAIL.n5 XRX.XCAP.O_PSET_TAIL.t8 0.228
R8180 XRX.XCAP.O_PSET_TAIL.n7 XRX.XCAP.O_PSET_TAIL.t5 0.228
R8181 XRX.XCAP.O_PSET_TAIL.n7 XRX.XCAP.O_PSET_TAIL.t6 0.228
R8182 XRX.XCAP.O_PSET_TAIL.n1 XRX.XCAP.O_PSET_TAIL.t2 0.228
R8183 XRX.XCAP.O_PSET_TAIL.n1 XRX.XCAP.O_PSET_TAIL.t1 0.228
R8184 XRX.XCAP.O_PSET_TAIL.n0 XRX.XCAP.O_PSET_TAIL.t0 0.228
R8185 XRX.XCAP.O_PSET_TAIL.n0 XRX.XCAP.O_PSET_TAIL.t3 0.228
R8186 XRX.XCAP.O_PSET_TAIL.n9 XRX.XCAP.O_PSET_TAIL.n8 0.189974
R8187 XRX.XCAP.O_PSET_TAIL.n8 XRX.XCAP.O_PSET_TAIL.n6 0.189974
R8188 XRX.XCAP.O_PSET_TAIL.n6 XRX.XCAP.O_PSET_TAIL.n4 0.189974
R8189 XRX.XCAP.O_PSET_TAIL XRX.XCAP.O_PSET_TAIL.n10 0.0396304
R8190 XRX.XCAP.E_PSET_TAIL.n10 XRX.XCAP.E_PSET_TAIL.n6 15.4962
R8191 XRX.XCAP.E_PSET_TAIL.n10 XRX.XCAP.E_PSET_TAIL.n9 12.1804
R8192 XRX.XCAP.E_PSET_TAIL.n1 XRX.XCAP.E_PSET_TAIL.t11 5.73764
R8193 XRX.XCAP.E_PSET_TAIL.n6 XRX.XCAP.E_PSET_TAIL.t4 5.54817
R8194 XRX.XCAP.E_PSET_TAIL.n9 XRX.XCAP.E_PSET_TAIL.n7 5.51014
R8195 XRX.XCAP.E_PSET_TAIL.n1 XRX.XCAP.E_PSET_TAIL.n0 5.32067
R8196 XRX.XCAP.E_PSET_TAIL.n3 XRX.XCAP.E_PSET_TAIL.n2 5.32067
R8197 XRX.XCAP.E_PSET_TAIL.n5 XRX.XCAP.E_PSET_TAIL.n4 5.32067
R8198 XRX.XCAP.E_PSET_TAIL.n9 XRX.XCAP.E_PSET_TAIL.n8 5.32067
R8199 XRX.XCAP.E_PSET_TAIL.n0 XRX.XCAP.E_PSET_TAIL.t9 0.228
R8200 XRX.XCAP.E_PSET_TAIL.n0 XRX.XCAP.E_PSET_TAIL.t10 0.228
R8201 XRX.XCAP.E_PSET_TAIL.n2 XRX.XCAP.E_PSET_TAIL.t7 0.228
R8202 XRX.XCAP.E_PSET_TAIL.n2 XRX.XCAP.E_PSET_TAIL.t8 0.228
R8203 XRX.XCAP.E_PSET_TAIL.n4 XRX.XCAP.E_PSET_TAIL.t5 0.228
R8204 XRX.XCAP.E_PSET_TAIL.n4 XRX.XCAP.E_PSET_TAIL.t6 0.228
R8205 XRX.XCAP.E_PSET_TAIL.n7 XRX.XCAP.E_PSET_TAIL.t1 0.228
R8206 XRX.XCAP.E_PSET_TAIL.n7 XRX.XCAP.E_PSET_TAIL.t0 0.228
R8207 XRX.XCAP.E_PSET_TAIL.n8 XRX.XCAP.E_PSET_TAIL.t3 0.228
R8208 XRX.XCAP.E_PSET_TAIL.n8 XRX.XCAP.E_PSET_TAIL.t2 0.228
R8209 XRX.XCAP.E_PSET_TAIL.n6 XRX.XCAP.E_PSET_TAIL.n5 0.189974
R8210 XRX.XCAP.E_PSET_TAIL.n5 XRX.XCAP.E_PSET_TAIL.n3 0.189974
R8211 XRX.XCAP.E_PSET_TAIL.n3 XRX.XCAP.E_PSET_TAIL.n1 0.189974
R8212 XRX.XCAP.E_PSET_TAIL XRX.XCAP.E_PSET_TAIL.n10 0.0396304
R8213 XRX.XCAP.O_QI.n0 XRX.XCAP.O_QI.t19 113.632
R8214 XRX.XCAP.O_QI.n16 XRX.XCAP.O_QI.t12 113.618
R8215 XRX.XCAP.O_QI.n16 XRX.XCAP.O_QI.t13 113.618
R8216 XRX.XCAP.O_QI.n15 XRX.XCAP.O_QI.t16 113.618
R8217 XRX.XCAP.O_QI.n15 XRX.XCAP.O_QI.t17 113.618
R8218 XRX.XCAP.O_QI.n0 XRX.XCAP.O_QI.t18 113.603
R8219 XRX.XCAP.O_QI.n1 XRX.XCAP.O_QI.t15 61.4885
R8220 XRX.XCAP.O_QI.n1 XRX.XCAP.O_QI.t14 61.4598
R8221 XRX.XCAP.O_QI.n2 XRX.XCAP.O_QI.n0 21.3118
R8222 XRX.XCAP.O_QI.n17 XRX.XCAP.O_QI.n15 19.4852
R8223 XRX.XCAP.O_QI.n17 XRX.XCAP.O_QI.n16 17.5287
R8224 XRX.XCAP.O_QI.n2 XRX.XCAP.O_QI.n1 16.2249
R8225 XRX.XCAP.O_QI.n14 XRX.XCAP.O_QI.n2 10.9375
R8226 XRX.XCAP.O_QI.n13 XRX.XCAP.O_QI.n12 9.70485
R8227 XRX.XCAP.O_QI.n7 XRX.XCAP.O_QI.n5 7.43528
R8228 XRX.XCAP.O_QI.n11 XRX.XCAP.O_QI.t0 5.7796
R8229 XRX.XCAP.O_QI.n8 XRX.XCAP.O_QI.t1 5.7796
R8230 XRX.XCAP.O_QI.n4 XRX.XCAP.O_QI.t7 5.73764
R8231 XRX.XCAP.O_QI.n6 XRX.XCAP.O_QI.t10 5.73764
R8232 XRX.XCAP.O_QI.n12 XRX.XCAP.O_QI.t5 5.68486
R8233 XRX.XCAP.O_QI.n5 XRX.XCAP.O_QI.t6 5.6429
R8234 XRX.XCAP.O_QI.n8 XRX.XCAP.O_QI.t2 5.59012
R8235 XRX.XCAP.O_QI.n6 XRX.XCAP.O_QI.t11 5.54817
R8236 XRX.XCAP.O_QI.n11 XRX.XCAP.O_QI.n10 5.38537
R8237 XRX.XCAP.O_QI.n4 XRX.XCAP.O_QI.n3 5.32067
R8238 XRX.XCAP.O_QI.n9 XRX.XCAP.O_QI.n7 4.8918
R8239 XRX.XCAP.O_QI.n7 XRX.XCAP.O_QI.n6 4.5005
R8240 XRX.XCAP.O_QI.n9 XRX.XCAP.O_QI.n8 4.5005
R8241 XRX.XCAP.O_QI.n14 XRX.XCAP.O_QI.n13 4.5005
R8242 XRX.XCAP.O_QI.n18 XRX.XCAP.O_QI.n17 4.5005
R8243 XRX.XCAP.O_QI.n18 XRX.XCAP.O_QI.n14 2.1918
R8244 XRX.XCAP.O_QI.n3 XRX.XCAP.O_QI.t9 0.228
R8245 XRX.XCAP.O_QI.n3 XRX.XCAP.O_QI.t8 0.228
R8246 XRX.XCAP.O_QI.n10 XRX.XCAP.O_QI.t4 0.20525
R8247 XRX.XCAP.O_QI.n10 XRX.XCAP.O_QI.t3 0.20525
R8248 XRX.XCAP.O_QI.n12 XRX.XCAP.O_QI.n11 0.0952368
R8249 XRX.XCAP.O_QI.n5 XRX.XCAP.O_QI.n4 0.0952368
R8250 XRX.XCAP.O_QI.n13 XRX.XCAP.O_QI.n9 0.0787609
R8251 XRX.XCAP.O_QI XRX.XCAP.O_QI.n18 0.0396304
R8252 XRX.XCAP.ODD_DB_BUF.n18 XRX.XCAP.ODD_DB_BUF.t12 113.632
R8253 XRX.XCAP.ODD_DB_BUF.n12 XRX.XCAP.ODD_DB_BUF.t16 113.632
R8254 XRX.XCAP.ODD_DB_BUF.n21 XRX.XCAP.ODD_DB_BUF.t15 109.174
R8255 XRX.XCAP.ODD_DB_BUF.n20 XRX.XCAP.ODD_DB_BUF.t14 109.174
R8256 XRX.XCAP.ODD_DB_BUF.n19 XRX.XCAP.ODD_DB_BUF.t13 109.174
R8257 XRX.XCAP.ODD_DB_BUF.n13 XRX.XCAP.ODD_DB_BUF.t17 109.174
R8258 XRX.XCAP.ODD_DB_BUF.n14 XRX.XCAP.ODD_DB_BUF.t18 109.174
R8259 XRX.XCAP.ODD_DB_BUF.n15 XRX.XCAP.ODD_DB_BUF.t19 109.174
R8260 XRX.XCAP.ODD_DB_BUF.n23 XRX.XCAP.ODD_DB_BUF.n22 21.6707
R8261 XRX.XCAP.ODD_DB_BUF.n22 XRX.XCAP.ODD_DB_BUF.n21 18.4942
R8262 XRX.XCAP.ODD_DB_BUF.n20 XRX.XCAP.ODD_DB_BUF.n17 18.4942
R8263 XRX.XCAP.ODD_DB_BUF.n14 XRX.XCAP.ODD_DB_BUF.n11 18.4942
R8264 XRX.XCAP.ODD_DB_BUF.n16 XRX.XCAP.ODD_DB_BUF.n15 18.4942
R8265 XRX.XCAP.ODD_DB_BUF.n21 XRX.XCAP.ODD_DB_BUF.n20 11.6805
R8266 XRX.XCAP.ODD_DB_BUF.n20 XRX.XCAP.ODD_DB_BUF.n19 11.6805
R8267 XRX.XCAP.ODD_DB_BUF.n14 XRX.XCAP.ODD_DB_BUF.n13 11.6805
R8268 XRX.XCAP.ODD_DB_BUF.n15 XRX.XCAP.ODD_DB_BUF.n14 11.6805
R8269 XRX.XCAP.ODD_DB_BUF.n10 XRX.XCAP.ODD_DB_BUF.n2 10.3701
R8270 XRX.XCAP.ODD_DB_BUF.n23 XRX.XCAP.ODD_DB_BUF.n16 9.77502
R8271 XRX.XCAP.ODD_DB_BUF.n24 XRX.XCAP.ODD_DB_BUF.n10 7.94398
R8272 XRX.XCAP.ODD_DB_BUF.n18 XRX.XCAP.ODD_DB_BUF.n17 7.17687
R8273 XRX.XCAP.ODD_DB_BUF.n12 XRX.XCAP.ODD_DB_BUF.n11 7.17687
R8274 XRX.XCAP.ODD_DB_BUF.n1 XRX.XCAP.ODD_DB_BUF.t3 5.7796
R8275 XRX.XCAP.ODD_DB_BUF.n4 XRX.XCAP.ODD_DB_BUF.t11 5.73764
R8276 XRX.XCAP.ODD_DB_BUF.n8 XRX.XCAP.ODD_DB_BUF.t4 5.73764
R8277 XRX.XCAP.ODD_DB_BUF.n2 XRX.XCAP.ODD_DB_BUF.t0 5.68486
R8278 XRX.XCAP.ODD_DB_BUF.n1 XRX.XCAP.ODD_DB_BUF.n0 5.38537
R8279 XRX.XCAP.ODD_DB_BUF.n4 XRX.XCAP.ODD_DB_BUF.n3 5.32067
R8280 XRX.XCAP.ODD_DB_BUF.n6 XRX.XCAP.ODD_DB_BUF.n5 5.32067
R8281 XRX.XCAP.ODD_DB_BUF.n8 XRX.XCAP.ODD_DB_BUF.n7 5.32067
R8282 XRX.XCAP.ODD_DB_BUF.n10 XRX.XCAP.ODD_DB_BUF.n9 4.5005
R8283 XRX.XCAP.ODD_DB_BUF.n24 XRX.XCAP.ODD_DB_BUF.n23 4.5005
R8284 XRX.XCAP.ODD_DB_BUF.n19 XRX.XCAP.ODD_DB_BUF.n18 4.42851
R8285 XRX.XCAP.ODD_DB_BUF.n13 XRX.XCAP.ODD_DB_BUF.n12 4.42851
R8286 XRX.XCAP.ODD_DB_BUF.n3 XRX.XCAP.ODD_DB_BUF.t9 0.228
R8287 XRX.XCAP.ODD_DB_BUF.n3 XRX.XCAP.ODD_DB_BUF.t10 0.228
R8288 XRX.XCAP.ODD_DB_BUF.n5 XRX.XCAP.ODD_DB_BUF.t7 0.228
R8289 XRX.XCAP.ODD_DB_BUF.n5 XRX.XCAP.ODD_DB_BUF.t8 0.228
R8290 XRX.XCAP.ODD_DB_BUF.n7 XRX.XCAP.ODD_DB_BUF.t5 0.228
R8291 XRX.XCAP.ODD_DB_BUF.n7 XRX.XCAP.ODD_DB_BUF.t6 0.228
R8292 XRX.XCAP.ODD_DB_BUF.n0 XRX.XCAP.ODD_DB_BUF.t1 0.20525
R8293 XRX.XCAP.ODD_DB_BUF.n0 XRX.XCAP.ODD_DB_BUF.t2 0.20525
R8294 XRX.XCAP.ODD_DB_BUF.n6 XRX.XCAP.ODD_DB_BUF.n4 0.189974
R8295 XRX.XCAP.ODD_DB_BUF.n22 XRX.XCAP.ODD_DB_BUF.n17 0.1205
R8296 XRX.XCAP.ODD_DB_BUF.n16 XRX.XCAP.ODD_DB_BUF.n11 0.1205
R8297 XRX.XCAP.ODD_DB_BUF.n9 XRX.XCAP.ODD_DB_BUF.n8 0.0952368
R8298 XRX.XCAP.ODD_DB_BUF.n9 XRX.XCAP.ODD_DB_BUF.n6 0.0952368
R8299 XRX.XCAP.ODD_DB_BUF.n2 XRX.XCAP.ODD_DB_BUF.n1 0.0952368
R8300 XRX.XCAP.ODD_DB_BUF XRX.XCAP.ODD_DB_BUF.n24 0.0396304
R8301 XRX.XCAP.EVEN_DB_BUF.n7 XRX.XCAP.EVEN_DB_BUF.t12 113.632
R8302 XRX.XCAP.EVEN_DB_BUF.n1 XRX.XCAP.EVEN_DB_BUF.t16 113.632
R8303 XRX.XCAP.EVEN_DB_BUF.n10 XRX.XCAP.EVEN_DB_BUF.t15 109.174
R8304 XRX.XCAP.EVEN_DB_BUF.n9 XRX.XCAP.EVEN_DB_BUF.t14 109.174
R8305 XRX.XCAP.EVEN_DB_BUF.n8 XRX.XCAP.EVEN_DB_BUF.t13 109.174
R8306 XRX.XCAP.EVEN_DB_BUF.n2 XRX.XCAP.EVEN_DB_BUF.t17 109.174
R8307 XRX.XCAP.EVEN_DB_BUF.n3 XRX.XCAP.EVEN_DB_BUF.t18 109.174
R8308 XRX.XCAP.EVEN_DB_BUF.n4 XRX.XCAP.EVEN_DB_BUF.t19 109.174
R8309 XRX.XCAP.EVEN_DB_BUF.n12 XRX.XCAP.EVEN_DB_BUF.n11 21.1228
R8310 XRX.XCAP.EVEN_DB_BUF.n11 XRX.XCAP.EVEN_DB_BUF.n10 18.4942
R8311 XRX.XCAP.EVEN_DB_BUF.n9 XRX.XCAP.EVEN_DB_BUF.n6 18.4942
R8312 XRX.XCAP.EVEN_DB_BUF.n3 XRX.XCAP.EVEN_DB_BUF.n0 18.4942
R8313 XRX.XCAP.EVEN_DB_BUF.n5 XRX.XCAP.EVEN_DB_BUF.n4 18.4942
R8314 XRX.XCAP.EVEN_DB_BUF.n10 XRX.XCAP.EVEN_DB_BUF.n9 11.6805
R8315 XRX.XCAP.EVEN_DB_BUF.n9 XRX.XCAP.EVEN_DB_BUF.n8 11.6805
R8316 XRX.XCAP.EVEN_DB_BUF.n3 XRX.XCAP.EVEN_DB_BUF.n2 11.6805
R8317 XRX.XCAP.EVEN_DB_BUF.n4 XRX.XCAP.EVEN_DB_BUF.n3 11.6805
R8318 XRX.XCAP.EVEN_DB_BUF.n23 XRX.XCAP.EVEN_DB_BUF.n15 10.3701
R8319 XRX.XCAP.EVEN_DB_BUF.n12 XRX.XCAP.EVEN_DB_BUF.n5 10.3228
R8320 XRX.XCAP.EVEN_DB_BUF.n7 XRX.XCAP.EVEN_DB_BUF.n6 7.17687
R8321 XRX.XCAP.EVEN_DB_BUF.n1 XRX.XCAP.EVEN_DB_BUF.n0 7.17687
R8322 XRX.XCAP.EVEN_DB_BUF.n24 XRX.XCAP.EVEN_DB_BUF.n12 6.53528
R8323 XRX.XCAP.EVEN_DB_BUF.n14 XRX.XCAP.EVEN_DB_BUF.t3 5.7796
R8324 XRX.XCAP.EVEN_DB_BUF.n17 XRX.XCAP.EVEN_DB_BUF.t11 5.73764
R8325 XRX.XCAP.EVEN_DB_BUF.n21 XRX.XCAP.EVEN_DB_BUF.t4 5.73764
R8326 XRX.XCAP.EVEN_DB_BUF.n15 XRX.XCAP.EVEN_DB_BUF.t0 5.68486
R8327 XRX.XCAP.EVEN_DB_BUF.n14 XRX.XCAP.EVEN_DB_BUF.n13 5.38537
R8328 XRX.XCAP.EVEN_DB_BUF.n17 XRX.XCAP.EVEN_DB_BUF.n16 5.32067
R8329 XRX.XCAP.EVEN_DB_BUF.n19 XRX.XCAP.EVEN_DB_BUF.n18 5.32067
R8330 XRX.XCAP.EVEN_DB_BUF.n21 XRX.XCAP.EVEN_DB_BUF.n20 5.32067
R8331 XRX.XCAP.EVEN_DB_BUF.n24 XRX.XCAP.EVEN_DB_BUF.n23 4.73528
R8332 XRX.XCAP.EVEN_DB_BUF.n23 XRX.XCAP.EVEN_DB_BUF.n22 4.5005
R8333 XRX.XCAP.EVEN_DB_BUF.n8 XRX.XCAP.EVEN_DB_BUF.n7 4.42851
R8334 XRX.XCAP.EVEN_DB_BUF.n2 XRX.XCAP.EVEN_DB_BUF.n1 4.42851
R8335 XRX.XCAP.EVEN_DB_BUF.n16 XRX.XCAP.EVEN_DB_BUF.t9 0.228
R8336 XRX.XCAP.EVEN_DB_BUF.n16 XRX.XCAP.EVEN_DB_BUF.t10 0.228
R8337 XRX.XCAP.EVEN_DB_BUF.n18 XRX.XCAP.EVEN_DB_BUF.t7 0.228
R8338 XRX.XCAP.EVEN_DB_BUF.n18 XRX.XCAP.EVEN_DB_BUF.t8 0.228
R8339 XRX.XCAP.EVEN_DB_BUF.n20 XRX.XCAP.EVEN_DB_BUF.t5 0.228
R8340 XRX.XCAP.EVEN_DB_BUF.n20 XRX.XCAP.EVEN_DB_BUF.t6 0.228
R8341 XRX.XCAP.EVEN_DB_BUF.n13 XRX.XCAP.EVEN_DB_BUF.t1 0.20525
R8342 XRX.XCAP.EVEN_DB_BUF.n13 XRX.XCAP.EVEN_DB_BUF.t2 0.20525
R8343 XRX.XCAP.EVEN_DB_BUF.n19 XRX.XCAP.EVEN_DB_BUF.n17 0.189974
R8344 XRX.XCAP.EVEN_DB_BUF.n11 XRX.XCAP.EVEN_DB_BUF.n6 0.1205
R8345 XRX.XCAP.EVEN_DB_BUF.n5 XRX.XCAP.EVEN_DB_BUF.n0 0.1205
R8346 XRX.XCAP.EVEN_DB_BUF.n22 XRX.XCAP.EVEN_DB_BUF.n21 0.0952368
R8347 XRX.XCAP.EVEN_DB_BUF.n22 XRX.XCAP.EVEN_DB_BUF.n19 0.0952368
R8348 XRX.XCAP.EVEN_DB_BUF.n15 XRX.XCAP.EVEN_DB_BUF.n14 0.0952368
R8349 XRX.XCAP.EVEN_DB_BUF XRX.XCAP.EVEN_DB_BUF.n24 0.0396304
R8350 XRX.XCAP.E_QI.n15 XRX.XCAP.E_QI.t19 113.632
R8351 XRX.XCAP.E_QI.n1 XRX.XCAP.E_QI.t12 113.618
R8352 XRX.XCAP.E_QI.n1 XRX.XCAP.E_QI.t13 113.618
R8353 XRX.XCAP.E_QI.n0 XRX.XCAP.E_QI.t16 113.618
R8354 XRX.XCAP.E_QI.n0 XRX.XCAP.E_QI.t17 113.618
R8355 XRX.XCAP.E_QI.n15 XRX.XCAP.E_QI.t18 113.603
R8356 XRX.XCAP.E_QI.n16 XRX.XCAP.E_QI.t15 61.4885
R8357 XRX.XCAP.E_QI.n16 XRX.XCAP.E_QI.t14 61.4598
R8358 XRX.XCAP.E_QI.n17 XRX.XCAP.E_QI.n15 21.3118
R8359 XRX.XCAP.E_QI.n2 XRX.XCAP.E_QI.n0 20.0331
R8360 XRX.XCAP.E_QI.n2 XRX.XCAP.E_QI.n1 16.9809
R8361 XRX.XCAP.E_QI.n17 XRX.XCAP.E_QI.n16 16.2249
R8362 XRX.XCAP.E_QI.n13 XRX.XCAP.E_QI.n12 9.15702
R8363 XRX.XCAP.E_QI.n7 XRX.XCAP.E_QI.n5 7.43528
R8364 XRX.XCAP.E_QI.n14 XRX.XCAP.E_QI.n2 7.00485
R8365 XRX.XCAP.E_QI.n18 XRX.XCAP.E_QI.n17 6.32007
R8366 XRX.XCAP.E_QI.n11 XRX.XCAP.E_QI.t7 5.7796
R8367 XRX.XCAP.E_QI.n8 XRX.XCAP.E_QI.t10 5.7796
R8368 XRX.XCAP.E_QI.n4 XRX.XCAP.E_QI.t3 5.73764
R8369 XRX.XCAP.E_QI.n6 XRX.XCAP.E_QI.t8 5.73764
R8370 XRX.XCAP.E_QI.n12 XRX.XCAP.E_QI.t4 5.68486
R8371 XRX.XCAP.E_QI.n5 XRX.XCAP.E_QI.t0 5.6429
R8372 XRX.XCAP.E_QI.n8 XRX.XCAP.E_QI.t11 5.59012
R8373 XRX.XCAP.E_QI.n6 XRX.XCAP.E_QI.t9 5.54817
R8374 XRX.XCAP.E_QI.n11 XRX.XCAP.E_QI.n10 5.38537
R8375 XRX.XCAP.E_QI.n4 XRX.XCAP.E_QI.n3 5.32067
R8376 XRX.XCAP.E_QI.n9 XRX.XCAP.E_QI.n7 4.8918
R8377 XRX.XCAP.E_QI.n7 XRX.XCAP.E_QI.n6 4.5005
R8378 XRX.XCAP.E_QI.n9 XRX.XCAP.E_QI.n8 4.5005
R8379 XRX.XCAP.E_QI.n14 XRX.XCAP.E_QI.n13 4.5005
R8380 XRX.XCAP.E_QI.n18 XRX.XCAP.E_QI.n14 4.22659
R8381 XRX.XCAP.E_QI.n13 XRX.XCAP.E_QI.n9 0.626587
R8382 XRX.XCAP.E_QI.n3 XRX.XCAP.E_QI.t1 0.228
R8383 XRX.XCAP.E_QI.n3 XRX.XCAP.E_QI.t2 0.228
R8384 XRX.XCAP.E_QI.n10 XRX.XCAP.E_QI.t5 0.20525
R8385 XRX.XCAP.E_QI.n10 XRX.XCAP.E_QI.t6 0.20525
R8386 XRX.XCAP.E_QI.n5 XRX.XCAP.E_QI.n4 0.0952368
R8387 XRX.XCAP.E_QI.n12 XRX.XCAP.E_QI.n11 0.0952368
R8388 XRX.XCAP.E_QI XRX.XCAP.E_QI.n18 0.0396304
R8389 XRX.XCAP.O_QBBUF.n0 XRX.XCAP.O_QBBUF.t7 113.632
R8390 XRX.XCAP.O_QBBUF.n3 XRX.XCAP.O_QBBUF.t10 113.632
R8391 XRX.XCAP.O_QBBUF.n7 XRX.XCAP.O_QBBUF.t6 113.629
R8392 XRX.XCAP.O_QBBUF.n5 XRX.XCAP.O_QBBUF.t4 109.174
R8393 XRX.XCAP.O_QBBUF.n6 XRX.XCAP.O_QBBUF.t5 109.174
R8394 XRX.XCAP.O_QBBUF.n1 XRX.XCAP.O_QBBUF.t8 109.174
R8395 XRX.XCAP.O_QBBUF.n2 XRX.XCAP.O_QBBUF.t9 109.174
R8396 XRX.XCAP.O_QBBUF.n8 XRX.XCAP.O_QBBUF.n5 18.6022
R8397 XRX.XCAP.O_QBBUF.n9 XRX.XCAP.O_QBBUF.n4 17.394
R8398 XRX.XCAP.O_QBBUF.n6 XRX.XCAP.O_QBBUF.n5 11.6805
R8399 XRX.XCAP.O_QBBUF.n2 XRX.XCAP.O_QBBUF.n1 11.6805
R8400 XRX.XCAP.O_QBBUF.n12 XRX.XCAP.O_QBBUF.n10 10.4648
R8401 XRX.XCAP.O_QBBUF.n9 XRX.XCAP.O_QBBUF.n8 9.21572
R8402 XRX.XCAP.O_QBBUF.n13 XRX.XCAP.O_QBBUF.n9 7.16137
R8403 XRX.XCAP.O_QBBUF.n4 XRX.XCAP.O_QBBUF.n0 7.10487
R8404 XRX.XCAP.O_QBBUF.n4 XRX.XCAP.O_QBBUF.n3 7.10487
R8405 XRX.XCAP.O_QBBUF.n8 XRX.XCAP.O_QBBUF.n7 7.05405
R8406 XRX.XCAP.O_QBBUF.n11 XRX.XCAP.O_QBBUF.t1 6.07983
R8407 XRX.XCAP.O_QBBUF.n11 XRX.XCAP.O_QBBUF.t0 5.89036
R8408 XRX.XCAP.O_QBBUF.n10 XRX.XCAP.O_QBBUF.t3 5.73764
R8409 XRX.XCAP.O_QBBUF.n10 XRX.XCAP.O_QBBUF.t2 5.54817
R8410 XRX.XCAP.O_QBBUF.n13 XRX.XCAP.O_QBBUF.n12 5.43963
R8411 XRX.XCAP.O_QBBUF.n12 XRX.XCAP.O_QBBUF.n11 4.59524
R8412 XRX.XCAP.O_QBBUF.n7 XRX.XCAP.O_QBBUF.n6 4.4296
R8413 XRX.XCAP.O_QBBUF.n1 XRX.XCAP.O_QBBUF.n0 4.42851
R8414 XRX.XCAP.O_QBBUF.n3 XRX.XCAP.O_QBBUF.n2 4.42851
R8415 XRX.XCAP.O_QBBUF XRX.XCAP.O_QBBUF.n13 0.0396304
R8416 XRX.XCAP.O_QBUF.n0 XRX.XCAP.O_QBUF.t7 113.632
R8417 XRX.XCAP.O_QBUF.n3 XRX.XCAP.O_QBUF.t10 113.632
R8418 XRX.XCAP.O_QBUF.n7 XRX.XCAP.O_QBUF.t6 113.629
R8419 XRX.XCAP.O_QBUF.n5 XRX.XCAP.O_QBUF.t4 109.174
R8420 XRX.XCAP.O_QBUF.n6 XRX.XCAP.O_QBUF.t5 109.174
R8421 XRX.XCAP.O_QBUF.n1 XRX.XCAP.O_QBUF.t8 109.174
R8422 XRX.XCAP.O_QBUF.n2 XRX.XCAP.O_QBUF.t9 109.174
R8423 XRX.XCAP.O_QBUF.n8 XRX.XCAP.O_QBUF.n5 18.6022
R8424 XRX.XCAP.O_QBUF.n9 XRX.XCAP.O_QBUF.n4 17.1201
R8425 XRX.XCAP.O_QBUF.n6 XRX.XCAP.O_QBUF.n5 11.6805
R8426 XRX.XCAP.O_QBUF.n2 XRX.XCAP.O_QBUF.n1 11.6805
R8427 XRX.XCAP.O_QBUF.n12 XRX.XCAP.O_QBUF.n10 10.4648
R8428 XRX.XCAP.O_QBUF.n9 XRX.XCAP.O_QBUF.n8 9.48963
R8429 XRX.XCAP.O_QBUF.n13 XRX.XCAP.O_QBUF.n9 7.16137
R8430 XRX.XCAP.O_QBUF.n4 XRX.XCAP.O_QBUF.n0 7.10487
R8431 XRX.XCAP.O_QBUF.n4 XRX.XCAP.O_QBUF.n3 7.10487
R8432 XRX.XCAP.O_QBUF.n8 XRX.XCAP.O_QBUF.n7 7.05405
R8433 XRX.XCAP.O_QBUF.n11 XRX.XCAP.O_QBUF.t2 6.07983
R8434 XRX.XCAP.O_QBUF.n11 XRX.XCAP.O_QBUF.t3 5.89036
R8435 XRX.XCAP.O_QBUF.n10 XRX.XCAP.O_QBUF.t0 5.73764
R8436 XRX.XCAP.O_QBUF.n10 XRX.XCAP.O_QBUF.t1 5.54817
R8437 XRX.XCAP.O_QBUF.n13 XRX.XCAP.O_QBUF.n12 5.16572
R8438 XRX.XCAP.O_QBUF.n12 XRX.XCAP.O_QBUF.n11 4.59524
R8439 XRX.XCAP.O_QBUF.n7 XRX.XCAP.O_QBUF.n6 4.4296
R8440 XRX.XCAP.O_QBUF.n1 XRX.XCAP.O_QBUF.n0 4.42851
R8441 XRX.XCAP.O_QBUF.n3 XRX.XCAP.O_QBUF.n2 4.42851
R8442 XRX.XCAP.O_QBUF XRX.XCAP.O_QBUF.n13 0.0396304
R8443 XRX.XCAP.E_QBUF.n3 XRX.XCAP.E_QBUF.t7 113.632
R8444 XRX.XCAP.E_QBUF.n6 XRX.XCAP.E_QBUF.t10 113.632
R8445 XRX.XCAP.E_QBUF.n10 XRX.XCAP.E_QBUF.t6 113.629
R8446 XRX.XCAP.E_QBUF.n8 XRX.XCAP.E_QBUF.t4 109.174
R8447 XRX.XCAP.E_QBUF.n9 XRX.XCAP.E_QBUF.t5 109.174
R8448 XRX.XCAP.E_QBUF.n4 XRX.XCAP.E_QBUF.t8 109.174
R8449 XRX.XCAP.E_QBUF.n5 XRX.XCAP.E_QBUF.t9 109.174
R8450 XRX.XCAP.E_QBUF.n11 XRX.XCAP.E_QBUF.n8 18.6022
R8451 XRX.XCAP.E_QBUF.n12 XRX.XCAP.E_QBUF.n7 17.6092
R8452 XRX.XCAP.E_QBUF.n9 XRX.XCAP.E_QBUF.n8 11.6805
R8453 XRX.XCAP.E_QBUF.n5 XRX.XCAP.E_QBUF.n4 11.6805
R8454 XRX.XCAP.E_QBUF.n2 XRX.XCAP.E_QBUF.n0 10.4648
R8455 XRX.XCAP.E_QBUF.n12 XRX.XCAP.E_QBUF.n11 9.0005
R8456 XRX.XCAP.E_QBUF.n13 XRX.XCAP.E_QBUF.n2 7.74833
R8457 XRX.XCAP.E_QBUF.n7 XRX.XCAP.E_QBUF.n3 7.10487
R8458 XRX.XCAP.E_QBUF.n7 XRX.XCAP.E_QBUF.n6 7.10487
R8459 XRX.XCAP.E_QBUF.n11 XRX.XCAP.E_QBUF.n10 7.05405
R8460 XRX.XCAP.E_QBUF.n1 XRX.XCAP.E_QBUF.t2 6.07983
R8461 XRX.XCAP.E_QBUF.n1 XRX.XCAP.E_QBUF.t3 5.89036
R8462 XRX.XCAP.E_QBUF.n0 XRX.XCAP.E_QBUF.t0 5.73764
R8463 XRX.XCAP.E_QBUF.n0 XRX.XCAP.E_QBUF.t1 5.54817
R8464 XRX.XCAP.E_QBUF.n2 XRX.XCAP.E_QBUF.n1 4.59524
R8465 XRX.XCAP.E_QBUF.n13 XRX.XCAP.E_QBUF.n12 4.5592
R8466 XRX.XCAP.E_QBUF.n10 XRX.XCAP.E_QBUF.n9 4.4296
R8467 XRX.XCAP.E_QBUF.n4 XRX.XCAP.E_QBUF.n3 4.42851
R8468 XRX.XCAP.E_QBUF.n6 XRX.XCAP.E_QBUF.n5 4.42851
R8469 XRX.XCAP.E_QBUF XRX.XCAP.E_QBUF.n13 0.0396304
R8470 XRX.XCAP.E_QBBUF.n3 XRX.XCAP.E_QBBUF.t7 113.632
R8471 XRX.XCAP.E_QBBUF.n6 XRX.XCAP.E_QBBUF.t10 113.632
R8472 XRX.XCAP.E_QBBUF.n10 XRX.XCAP.E_QBBUF.t6 113.629
R8473 XRX.XCAP.E_QBBUF.n8 XRX.XCAP.E_QBBUF.t4 109.174
R8474 XRX.XCAP.E_QBBUF.n9 XRX.XCAP.E_QBBUF.t5 109.174
R8475 XRX.XCAP.E_QBBUF.n4 XRX.XCAP.E_QBBUF.t8 109.174
R8476 XRX.XCAP.E_QBBUF.n5 XRX.XCAP.E_QBBUF.t9 109.174
R8477 XRX.XCAP.E_QBBUF.n11 XRX.XCAP.E_QBBUF.n8 18.6022
R8478 XRX.XCAP.E_QBBUF.n12 XRX.XCAP.E_QBBUF.n7 17.6092
R8479 XRX.XCAP.E_QBBUF.n9 XRX.XCAP.E_QBBUF.n8 11.6805
R8480 XRX.XCAP.E_QBBUF.n5 XRX.XCAP.E_QBBUF.n4 11.6805
R8481 XRX.XCAP.E_QBBUF.n2 XRX.XCAP.E_QBBUF.n0 10.4648
R8482 XRX.XCAP.E_QBBUF.n12 XRX.XCAP.E_QBBUF.n11 9.0005
R8483 XRX.XCAP.E_QBBUF.n13 XRX.XCAP.E_QBBUF.n2 8.02224
R8484 XRX.XCAP.E_QBBUF.n7 XRX.XCAP.E_QBBUF.n3 7.10487
R8485 XRX.XCAP.E_QBBUF.n7 XRX.XCAP.E_QBBUF.n6 7.10487
R8486 XRX.XCAP.E_QBBUF.n11 XRX.XCAP.E_QBBUF.n10 7.05405
R8487 XRX.XCAP.E_QBBUF.n1 XRX.XCAP.E_QBBUF.t1 6.07983
R8488 XRX.XCAP.E_QBBUF.n1 XRX.XCAP.E_QBBUF.t0 5.89036
R8489 XRX.XCAP.E_QBBUF.n0 XRX.XCAP.E_QBBUF.t3 5.73764
R8490 XRX.XCAP.E_QBBUF.n0 XRX.XCAP.E_QBBUF.t2 5.54817
R8491 XRX.XCAP.E_QBBUF.n13 XRX.XCAP.E_QBBUF.n12 4.83311
R8492 XRX.XCAP.E_QBBUF.n2 XRX.XCAP.E_QBBUF.n1 4.59524
R8493 XRX.XCAP.E_QBBUF.n10 XRX.XCAP.E_QBBUF.n9 4.4296
R8494 XRX.XCAP.E_QBBUF.n4 XRX.XCAP.E_QBBUF.n3 4.42851
R8495 XRX.XCAP.E_QBBUF.n6 XRX.XCAP.E_QBBUF.n5 4.42851
R8496 XRX.XCAP.E_QBBUF XRX.XCAP.E_QBBUF.n13 0.0396304
R8497 XRX.XCAP.O_QBI.n14 XRX.XCAP.O_QBI.t19 113.632
R8498 XRX.XCAP.O_QBI.n4 XRX.XCAP.O_QBI.t12 113.618
R8499 XRX.XCAP.O_QBI.n4 XRX.XCAP.O_QBI.t13 113.618
R8500 XRX.XCAP.O_QBI.n2 XRX.XCAP.O_QBI.t16 113.618
R8501 XRX.XCAP.O_QBI.n2 XRX.XCAP.O_QBI.t17 113.618
R8502 XRX.XCAP.O_QBI.n14 XRX.XCAP.O_QBI.t18 113.603
R8503 XRX.XCAP.O_QBI.n15 XRX.XCAP.O_QBI.t15 61.4885
R8504 XRX.XCAP.O_QBI.n15 XRX.XCAP.O_QBI.t14 61.4598
R8505 XRX.XCAP.O_QBI.n16 XRX.XCAP.O_QBI.n14 21.4318
R8506 XRX.XCAP.O_QBI.n5 XRX.XCAP.O_QBI.n4 17.8026
R8507 XRX.XCAP.O_QBI.n16 XRX.XCAP.O_QBI.n15 16.3449
R8508 XRX.XCAP.O_QBI.n3 XRX.XCAP.O_QBI.n2 16.0613
R8509 XRX.XCAP.O_QBI.n3 XRX.XCAP.O_QBI.n1 14.0679
R8510 XRX.XCAP.O_QBI.n12 XRX.XCAP.O_QBI.n6 9.19615
R8511 XRX.XCAP.O_QBI.n11 XRX.XCAP.O_QBI.n9 7.43528
R8512 XRX.XCAP.O_QBI.n13 XRX.XCAP.O_QBI.n5 7.00485
R8513 XRX.XCAP.O_QBI.n10 XRX.XCAP.O_QBI.t3 5.7796
R8514 XRX.XCAP.O_QBI.n8 XRX.XCAP.O_QBI.t11 5.7796
R8515 XRX.XCAP.O_QBI.n1 XRX.XCAP.O_QBI.t1 5.73764
R8516 XRX.XCAP.O_QBI.n1 XRX.XCAP.O_QBI.t8 5.73764
R8517 XRX.XCAP.O_QBI.n6 XRX.XCAP.O_QBI.t5 5.73764
R8518 XRX.XCAP.O_QBI.n9 XRX.XCAP.O_QBI.t0 5.68486
R8519 XRX.XCAP.O_QBI.n10 XRX.XCAP.O_QBI.t2 5.59012
R8520 XRX.XCAP.O_QBI.n6 XRX.XCAP.O_QBI.t4 5.54817
R8521 XRX.XCAP.O_QBI.n17 XRX.XCAP.O_QBI.n16 5.49833
R8522 XRX.XCAP.O_QBI.n8 XRX.XCAP.O_QBI.n7 5.38537
R8523 XRX.XCAP.O_QBI.n1 XRX.XCAP.O_QBI.n0 5.32067
R8524 XRX.XCAP.O_QBI.n11 XRX.XCAP.O_QBI.n10 4.5005
R8525 XRX.XCAP.O_QBI.n13 XRX.XCAP.O_QBI.n12 4.5005
R8526 XRX.XCAP.O_QBI.n5 XRX.XCAP.O_QBI.n3 3.1505
R8527 XRX.XCAP.O_QBI.n17 XRX.XCAP.O_QBI.n13 2.89615
R8528 XRX.XCAP.O_QBI.n0 XRX.XCAP.O_QBI.t10 0.228
R8529 XRX.XCAP.O_QBI.n0 XRX.XCAP.O_QBI.t9 0.228
R8530 XRX.XCAP.O_QBI.n7 XRX.XCAP.O_QBI.t7 0.20525
R8531 XRX.XCAP.O_QBI.n7 XRX.XCAP.O_QBI.t6 0.20525
R8532 XRX.XCAP.O_QBI.n12 XRX.XCAP.O_QBI.n11 0.196152
R8533 XRX.XCAP.O_QBI.n9 XRX.XCAP.O_QBI.n8 0.0952368
R8534 XRX.XCAP.O_QBI XRX.XCAP.O_QBI.n17 0.0396304
R8535 XRX.XCAP.O_PRST_TAIL.n10 XRX.XCAP.O_PRST_TAIL.n2 19.1064
R8536 XRX.XCAP.O_PRST_TAIL.n10 XRX.XCAP.O_PRST_TAIL.n9 17.603
R8537 XRX.XCAP.O_PRST_TAIL.n4 XRX.XCAP.O_PRST_TAIL.t8 5.73764
R8538 XRX.XCAP.O_PRST_TAIL.n9 XRX.XCAP.O_PRST_TAIL.t1 5.54817
R8539 XRX.XCAP.O_PRST_TAIL.n2 XRX.XCAP.O_PRST_TAIL.n0 5.51014
R8540 XRX.XCAP.O_PRST_TAIL.n2 XRX.XCAP.O_PRST_TAIL.n1 5.32067
R8541 XRX.XCAP.O_PRST_TAIL.n4 XRX.XCAP.O_PRST_TAIL.n3 5.32067
R8542 XRX.XCAP.O_PRST_TAIL.n6 XRX.XCAP.O_PRST_TAIL.n5 5.32067
R8543 XRX.XCAP.O_PRST_TAIL.n8 XRX.XCAP.O_PRST_TAIL.n7 5.32067
R8544 XRX.XCAP.O_PRST_TAIL.n0 XRX.XCAP.O_PRST_TAIL.t10 0.228
R8545 XRX.XCAP.O_PRST_TAIL.n0 XRX.XCAP.O_PRST_TAIL.t0 0.228
R8546 XRX.XCAP.O_PRST_TAIL.n1 XRX.XCAP.O_PRST_TAIL.t9 0.228
R8547 XRX.XCAP.O_PRST_TAIL.n1 XRX.XCAP.O_PRST_TAIL.t11 0.228
R8548 XRX.XCAP.O_PRST_TAIL.n3 XRX.XCAP.O_PRST_TAIL.t6 0.228
R8549 XRX.XCAP.O_PRST_TAIL.n3 XRX.XCAP.O_PRST_TAIL.t7 0.228
R8550 XRX.XCAP.O_PRST_TAIL.n5 XRX.XCAP.O_PRST_TAIL.t4 0.228
R8551 XRX.XCAP.O_PRST_TAIL.n5 XRX.XCAP.O_PRST_TAIL.t5 0.228
R8552 XRX.XCAP.O_PRST_TAIL.n7 XRX.XCAP.O_PRST_TAIL.t2 0.228
R8553 XRX.XCAP.O_PRST_TAIL.n7 XRX.XCAP.O_PRST_TAIL.t3 0.228
R8554 XRX.XCAP.O_PRST_TAIL.n9 XRX.XCAP.O_PRST_TAIL.n8 0.189974
R8555 XRX.XCAP.O_PRST_TAIL.n8 XRX.XCAP.O_PRST_TAIL.n6 0.189974
R8556 XRX.XCAP.O_PRST_TAIL.n6 XRX.XCAP.O_PRST_TAIL.n4 0.189974
R8557 XRX.XCAP.O_PRST_TAIL XRX.XCAP.O_PRST_TAIL.n10 0.0396304
R8558 XRX.XCAP.E_PRST_TAIL.n10 XRX.XCAP.E_PRST_TAIL.n6 24.2305
R8559 XRX.XCAP.E_PRST_TAIL.n10 XRX.XCAP.E_PRST_TAIL.n9 17.0881
R8560 XRX.XCAP.E_PRST_TAIL.n1 XRX.XCAP.E_PRST_TAIL.t2 5.73764
R8561 XRX.XCAP.E_PRST_TAIL.n6 XRX.XCAP.E_PRST_TAIL.t9 5.54817
R8562 XRX.XCAP.E_PRST_TAIL.n9 XRX.XCAP.E_PRST_TAIL.n7 5.51014
R8563 XRX.XCAP.E_PRST_TAIL.n9 XRX.XCAP.E_PRST_TAIL.n8 5.32067
R8564 XRX.XCAP.E_PRST_TAIL.n5 XRX.XCAP.E_PRST_TAIL.n4 5.32067
R8565 XRX.XCAP.E_PRST_TAIL.n3 XRX.XCAP.E_PRST_TAIL.n2 5.32067
R8566 XRX.XCAP.E_PRST_TAIL.n1 XRX.XCAP.E_PRST_TAIL.n0 5.32067
R8567 XRX.XCAP.E_PRST_TAIL.n7 XRX.XCAP.E_PRST_TAIL.t10 0.228
R8568 XRX.XCAP.E_PRST_TAIL.n7 XRX.XCAP.E_PRST_TAIL.t1 0.228
R8569 XRX.XCAP.E_PRST_TAIL.n8 XRX.XCAP.E_PRST_TAIL.t0 0.228
R8570 XRX.XCAP.E_PRST_TAIL.n8 XRX.XCAP.E_PRST_TAIL.t11 0.228
R8571 XRX.XCAP.E_PRST_TAIL.n4 XRX.XCAP.E_PRST_TAIL.t7 0.228
R8572 XRX.XCAP.E_PRST_TAIL.n4 XRX.XCAP.E_PRST_TAIL.t8 0.228
R8573 XRX.XCAP.E_PRST_TAIL.n2 XRX.XCAP.E_PRST_TAIL.t5 0.228
R8574 XRX.XCAP.E_PRST_TAIL.n2 XRX.XCAP.E_PRST_TAIL.t6 0.228
R8575 XRX.XCAP.E_PRST_TAIL.n0 XRX.XCAP.E_PRST_TAIL.t3 0.228
R8576 XRX.XCAP.E_PRST_TAIL.n0 XRX.XCAP.E_PRST_TAIL.t4 0.228
R8577 XRX.XCAP.E_PRST_TAIL.n3 XRX.XCAP.E_PRST_TAIL.n1 0.189974
R8578 XRX.XCAP.E_PRST_TAIL.n5 XRX.XCAP.E_PRST_TAIL.n3 0.189974
R8579 XRX.XCAP.E_PRST_TAIL.n6 XRX.XCAP.E_PRST_TAIL.n5 0.189974
R8580 XRX.XCAP.E_PRST_TAIL XRX.XCAP.E_PRST_TAIL.n10 0.0396304
R8581 XRX.XCAP.E_QBI.n0 XRX.XCAP.E_QBI.t19 113.632
R8582 XRX.XCAP.E_QBI.n15 XRX.XCAP.E_QBI.t12 113.618
R8583 XRX.XCAP.E_QBI.n15 XRX.XCAP.E_QBI.t13 113.618
R8584 XRX.XCAP.E_QBI.n13 XRX.XCAP.E_QBI.t16 113.618
R8585 XRX.XCAP.E_QBI.n13 XRX.XCAP.E_QBI.t17 113.618
R8586 XRX.XCAP.E_QBI.n0 XRX.XCAP.E_QBI.t18 113.603
R8587 XRX.XCAP.E_QBI.n1 XRX.XCAP.E_QBI.t15 61.4885
R8588 XRX.XCAP.E_QBI.n1 XRX.XCAP.E_QBI.t14 61.4598
R8589 XRX.XCAP.E_QBI.n2 XRX.XCAP.E_QBI.n0 21.4318
R8590 XRX.XCAP.E_QBI.n16 XRX.XCAP.E_QBI.n15 17.2548
R8591 XRX.XCAP.E_QBI.n2 XRX.XCAP.E_QBI.n1 16.3449
R8592 XRX.XCAP.E_QBI.n14 XRX.XCAP.E_QBI.n13 16.0613
R8593 XRX.XCAP.E_QBI.n14 XRX.XCAP.E_QBI.n12 14.0679
R8594 XRX.XCAP.E_QBI.n10 XRX.XCAP.E_QBI.n2 10.194
R8595 XRX.XCAP.E_QBI.n5 XRX.XCAP.E_QBI.n3 9.3918
R8596 XRX.XCAP.E_QBI.n9 XRX.XCAP.E_QBI.n8 7.08311
R8597 XRX.XCAP.E_QBI.n4 XRX.XCAP.E_QBI.t5 5.7796
R8598 XRX.XCAP.E_QBI.n7 XRX.XCAP.E_QBI.t1 5.7796
R8599 XRX.XCAP.E_QBI.n12 XRX.XCAP.E_QBI.t3 5.73764
R8600 XRX.XCAP.E_QBI.n12 XRX.XCAP.E_QBI.t0 5.73764
R8601 XRX.XCAP.E_QBI.n3 XRX.XCAP.E_QBI.t7 5.73764
R8602 XRX.XCAP.E_QBI.n8 XRX.XCAP.E_QBI.t2 5.68486
R8603 XRX.XCAP.E_QBI.n4 XRX.XCAP.E_QBI.t4 5.59012
R8604 XRX.XCAP.E_QBI.n3 XRX.XCAP.E_QBI.t6 5.54817
R8605 XRX.XCAP.E_QBI.n7 XRX.XCAP.E_QBI.n6 5.38537
R8606 XRX.XCAP.E_QBI.n12 XRX.XCAP.E_QBI.n11 5.32067
R8607 XRX.XCAP.E_QBI.n5 XRX.XCAP.E_QBI.n4 4.5005
R8608 XRX.XCAP.E_QBI.n10 XRX.XCAP.E_QBI.n9 4.5005
R8609 XRX.XCAP.E_QBI.n17 XRX.XCAP.E_QBI.n16 4.5005
R8610 XRX.XCAP.E_QBI.n16 XRX.XCAP.E_QBI.n14 3.69833
R8611 XRX.XCAP.E_QBI.n17 XRX.XCAP.E_QBI.n10 2.1918
R8612 XRX.XCAP.E_QBI.n9 XRX.XCAP.E_QBI.n5 0.352674
R8613 XRX.XCAP.E_QBI.n11 XRX.XCAP.E_QBI.t11 0.228
R8614 XRX.XCAP.E_QBI.n11 XRX.XCAP.E_QBI.t10 0.228
R8615 XRX.XCAP.E_QBI.n6 XRX.XCAP.E_QBI.t9 0.20525
R8616 XRX.XCAP.E_QBI.n6 XRX.XCAP.E_QBI.t8 0.20525
R8617 XRX.XCAP.E_QBI.n8 XRX.XCAP.E_QBI.n7 0.0952368
R8618 XRX.XCAP.E_QBI XRX.XCAP.E_QBI.n17 0.0396304
R8619 XRX.XCAP.ODD_D_BUF.n19 XRX.XCAP.ODD_D_BUF.t12 113.632
R8620 XRX.XCAP.ODD_D_BUF.n12 XRX.XCAP.ODD_D_BUF.t19 113.632
R8621 XRX.XCAP.ODD_D_BUF.n22 XRX.XCAP.ODD_D_BUF.t15 109.174
R8622 XRX.XCAP.ODD_D_BUF.n21 XRX.XCAP.ODD_D_BUF.t14 109.174
R8623 XRX.XCAP.ODD_D_BUF.n20 XRX.XCAP.ODD_D_BUF.t13 109.174
R8624 XRX.XCAP.ODD_D_BUF.n15 XRX.XCAP.ODD_D_BUF.t16 109.174
R8625 XRX.XCAP.ODD_D_BUF.n14 XRX.XCAP.ODD_D_BUF.t17 109.174
R8626 XRX.XCAP.ODD_D_BUF.n13 XRX.XCAP.ODD_D_BUF.t18 109.174
R8627 XRX.XCAP.ODD_D_BUF.n24 XRX.XCAP.ODD_D_BUF.n23 23.4289
R8628 XRX.XCAP.ODD_D_BUF.n17 XRX.XCAP.ODD_D_BUF.n16 20.1159
R8629 XRX.XCAP.ODD_D_BUF.n23 XRX.XCAP.ODD_D_BUF.n22 18.4942
R8630 XRX.XCAP.ODD_D_BUF.n21 XRX.XCAP.ODD_D_BUF.n18 18.4942
R8631 XRX.XCAP.ODD_D_BUF.n16 XRX.XCAP.ODD_D_BUF.n15 18.4942
R8632 XRX.XCAP.ODD_D_BUF.n14 XRX.XCAP.ODD_D_BUF.n11 18.4942
R8633 XRX.XCAP.ODD_D_BUF.n22 XRX.XCAP.ODD_D_BUF.n21 11.6805
R8634 XRX.XCAP.ODD_D_BUF.n21 XRX.XCAP.ODD_D_BUF.n20 11.6805
R8635 XRX.XCAP.ODD_D_BUF.n15 XRX.XCAP.ODD_D_BUF.n14 11.6805
R8636 XRX.XCAP.ODD_D_BUF.n14 XRX.XCAP.ODD_D_BUF.n13 11.6805
R8637 XRX.XCAP.ODD_D_BUF.n10 XRX.XCAP.ODD_D_BUF.n2 10.3701
R8638 XRX.XCAP.ODD_D_BUF.n17 XRX.XCAP.ODD_D_BUF.n10 8.45267
R8639 XRX.XCAP.ODD_D_BUF.n19 XRX.XCAP.ODD_D_BUF.n18 7.17687
R8640 XRX.XCAP.ODD_D_BUF.n12 XRX.XCAP.ODD_D_BUF.n11 7.17687
R8641 XRX.XCAP.ODD_D_BUF.n1 XRX.XCAP.ODD_D_BUF.t3 5.7796
R8642 XRX.XCAP.ODD_D_BUF.n4 XRX.XCAP.ODD_D_BUF.t11 5.73764
R8643 XRX.XCAP.ODD_D_BUF.n8 XRX.XCAP.ODD_D_BUF.t4 5.73764
R8644 XRX.XCAP.ODD_D_BUF.n2 XRX.XCAP.ODD_D_BUF.t0 5.68486
R8645 XRX.XCAP.ODD_D_BUF.n1 XRX.XCAP.ODD_D_BUF.n0 5.38537
R8646 XRX.XCAP.ODD_D_BUF.n4 XRX.XCAP.ODD_D_BUF.n3 5.32067
R8647 XRX.XCAP.ODD_D_BUF.n6 XRX.XCAP.ODD_D_BUF.n5 5.32067
R8648 XRX.XCAP.ODD_D_BUF.n8 XRX.XCAP.ODD_D_BUF.n7 5.32067
R8649 XRX.XCAP.ODD_D_BUF.n10 XRX.XCAP.ODD_D_BUF.n9 4.5005
R8650 XRX.XCAP.ODD_D_BUF.n20 XRX.XCAP.ODD_D_BUF.n19 4.42851
R8651 XRX.XCAP.ODD_D_BUF.n13 XRX.XCAP.ODD_D_BUF.n12 4.42851
R8652 XRX.XCAP.ODD_D_BUF.n24 XRX.XCAP.ODD_D_BUF.n17 3.75702
R8653 XRX.XCAP.ODD_D_BUF.n3 XRX.XCAP.ODD_D_BUF.t9 0.228
R8654 XRX.XCAP.ODD_D_BUF.n3 XRX.XCAP.ODD_D_BUF.t10 0.228
R8655 XRX.XCAP.ODD_D_BUF.n5 XRX.XCAP.ODD_D_BUF.t7 0.228
R8656 XRX.XCAP.ODD_D_BUF.n5 XRX.XCAP.ODD_D_BUF.t8 0.228
R8657 XRX.XCAP.ODD_D_BUF.n7 XRX.XCAP.ODD_D_BUF.t5 0.228
R8658 XRX.XCAP.ODD_D_BUF.n7 XRX.XCAP.ODD_D_BUF.t6 0.228
R8659 XRX.XCAP.ODD_D_BUF.n0 XRX.XCAP.ODD_D_BUF.t1 0.20525
R8660 XRX.XCAP.ODD_D_BUF.n0 XRX.XCAP.ODD_D_BUF.t2 0.20525
R8661 XRX.XCAP.ODD_D_BUF.n6 XRX.XCAP.ODD_D_BUF.n4 0.189974
R8662 XRX.XCAP.ODD_D_BUF.n23 XRX.XCAP.ODD_D_BUF.n18 0.1205
R8663 XRX.XCAP.ODD_D_BUF.n16 XRX.XCAP.ODD_D_BUF.n11 0.1205
R8664 XRX.XCAP.ODD_D_BUF.n9 XRX.XCAP.ODD_D_BUF.n8 0.0952368
R8665 XRX.XCAP.ODD_D_BUF.n9 XRX.XCAP.ODD_D_BUF.n6 0.0952368
R8666 XRX.XCAP.ODD_D_BUF.n2 XRX.XCAP.ODD_D_BUF.n1 0.0952368
R8667 XRX.XCAP.ODD_D_BUF XRX.XCAP.ODD_D_BUF.n24 0.0396304
R8668 XRX.XCAP.EVEN_D_BUF.n1 XRX.XCAP.EVEN_D_BUF.t12 113.632
R8669 XRX.XCAP.EVEN_D_BUF.n7 XRX.XCAP.EVEN_D_BUF.t16 113.632
R8670 XRX.XCAP.EVEN_D_BUF.n4 XRX.XCAP.EVEN_D_BUF.t15 109.174
R8671 XRX.XCAP.EVEN_D_BUF.n3 XRX.XCAP.EVEN_D_BUF.t14 109.174
R8672 XRX.XCAP.EVEN_D_BUF.n2 XRX.XCAP.EVEN_D_BUF.t13 109.174
R8673 XRX.XCAP.EVEN_D_BUF.n8 XRX.XCAP.EVEN_D_BUF.t17 109.174
R8674 XRX.XCAP.EVEN_D_BUF.n9 XRX.XCAP.EVEN_D_BUF.t18 109.174
R8675 XRX.XCAP.EVEN_D_BUF.n10 XRX.XCAP.EVEN_D_BUF.t19 109.174
R8676 XRX.XCAP.EVEN_D_BUF.n12 XRX.XCAP.EVEN_D_BUF.n5 25.855
R8677 XRX.XCAP.EVEN_D_BUF.n12 XRX.XCAP.EVEN_D_BUF.n11 20.5437
R8678 XRX.XCAP.EVEN_D_BUF.n5 XRX.XCAP.EVEN_D_BUF.n4 18.4942
R8679 XRX.XCAP.EVEN_D_BUF.n3 XRX.XCAP.EVEN_D_BUF.n0 18.4942
R8680 XRX.XCAP.EVEN_D_BUF.n9 XRX.XCAP.EVEN_D_BUF.n6 18.4942
R8681 XRX.XCAP.EVEN_D_BUF.n11 XRX.XCAP.EVEN_D_BUF.n10 18.4942
R8682 XRX.XCAP.EVEN_D_BUF.n4 XRX.XCAP.EVEN_D_BUF.n3 11.6805
R8683 XRX.XCAP.EVEN_D_BUF.n3 XRX.XCAP.EVEN_D_BUF.n2 11.6805
R8684 XRX.XCAP.EVEN_D_BUF.n9 XRX.XCAP.EVEN_D_BUF.n8 11.6805
R8685 XRX.XCAP.EVEN_D_BUF.n10 XRX.XCAP.EVEN_D_BUF.n9 11.6805
R8686 XRX.XCAP.EVEN_D_BUF.n23 XRX.XCAP.EVEN_D_BUF.n22 10.3309
R8687 XRX.XCAP.EVEN_D_BUF.n1 XRX.XCAP.EVEN_D_BUF.n0 7.17687
R8688 XRX.XCAP.EVEN_D_BUF.n7 XRX.XCAP.EVEN_D_BUF.n6 7.17687
R8689 XRX.XCAP.EVEN_D_BUF.n21 XRX.XCAP.EVEN_D_BUF.t3 5.7796
R8690 XRX.XCAP.EVEN_D_BUF.n14 XRX.XCAP.EVEN_D_BUF.t11 5.73764
R8691 XRX.XCAP.EVEN_D_BUF.n18 XRX.XCAP.EVEN_D_BUF.t4 5.73764
R8692 XRX.XCAP.EVEN_D_BUF.n22 XRX.XCAP.EVEN_D_BUF.t0 5.68486
R8693 XRX.XCAP.EVEN_D_BUF.n21 XRX.XCAP.EVEN_D_BUF.n20 5.38537
R8694 XRX.XCAP.EVEN_D_BUF.n14 XRX.XCAP.EVEN_D_BUF.n13 5.32067
R8695 XRX.XCAP.EVEN_D_BUF.n16 XRX.XCAP.EVEN_D_BUF.n15 5.32067
R8696 XRX.XCAP.EVEN_D_BUF.n18 XRX.XCAP.EVEN_D_BUF.n17 5.32067
R8697 XRX.XCAP.EVEN_D_BUF.n23 XRX.XCAP.EVEN_D_BUF.n19 4.53963
R8698 XRX.XCAP.EVEN_D_BUF.n24 XRX.XCAP.EVEN_D_BUF.n23 4.5005
R8699 XRX.XCAP.EVEN_D_BUF.n2 XRX.XCAP.EVEN_D_BUF.n1 4.42851
R8700 XRX.XCAP.EVEN_D_BUF.n8 XRX.XCAP.EVEN_D_BUF.n7 4.42851
R8701 XRX.XCAP.EVEN_D_BUF.n24 XRX.XCAP.EVEN_D_BUF.n12 3.91354
R8702 XRX.XCAP.EVEN_D_BUF.n13 XRX.XCAP.EVEN_D_BUF.t9 0.228
R8703 XRX.XCAP.EVEN_D_BUF.n13 XRX.XCAP.EVEN_D_BUF.t10 0.228
R8704 XRX.XCAP.EVEN_D_BUF.n15 XRX.XCAP.EVEN_D_BUF.t7 0.228
R8705 XRX.XCAP.EVEN_D_BUF.n15 XRX.XCAP.EVEN_D_BUF.t8 0.228
R8706 XRX.XCAP.EVEN_D_BUF.n17 XRX.XCAP.EVEN_D_BUF.t5 0.228
R8707 XRX.XCAP.EVEN_D_BUF.n17 XRX.XCAP.EVEN_D_BUF.t6 0.228
R8708 XRX.XCAP.EVEN_D_BUF.n20 XRX.XCAP.EVEN_D_BUF.t1 0.20525
R8709 XRX.XCAP.EVEN_D_BUF.n20 XRX.XCAP.EVEN_D_BUF.t2 0.20525
R8710 XRX.XCAP.EVEN_D_BUF.n16 XRX.XCAP.EVEN_D_BUF.n14 0.189974
R8711 XRX.XCAP.EVEN_D_BUF.n5 XRX.XCAP.EVEN_D_BUF.n0 0.1205
R8712 XRX.XCAP.EVEN_D_BUF.n11 XRX.XCAP.EVEN_D_BUF.n6 0.1205
R8713 XRX.XCAP.EVEN_D_BUF.n19 XRX.XCAP.EVEN_D_BUF.n18 0.0952368
R8714 XRX.XCAP.EVEN_D_BUF.n19 XRX.XCAP.EVEN_D_BUF.n16 0.0952368
R8715 XRX.XCAP.EVEN_D_BUF.n22 XRX.XCAP.EVEN_D_BUF.n21 0.0952368
R8716 XRX.XCAP.EVEN_D_BUF XRX.XCAP.EVEN_D_BUF.n24 0.0396304
C0 XRX.XFRONT.XFE_E.NTAIL SAMP_E_P 1.55309f
C1 XRX.XCAP.E_QBBUF E_CAPTURE_CLKB 0.15018f
C2 XRX.XFRONT.XFE_E.NIP E_SENSE_CLK 2.64521f
C3 XRX.XCAP.ODD_DB_BUF XRX.XCAP.O_RST_TAIL 0.56945f
C4 XRX.XCAP.O_QBI O_CAPTURE_CLK 0.04327f
C5 XRX.XFRONT.XFE_O.H VDD 16.7985f
C6 VDD O_CAPTURE_CLK 2.33044f
C7 XRX.XFRONT.XFE_O.NIN SAMP_O_N 2.30328f
C8 RX_RAWN RX_BW_EN_N 0.3734f
C9 XRX.XCAP.E_QBBUF EVEN_Q 4.25991f
C10 O_CAPTURE_CLKB ODD_Q 0.07511f
C11 XRX.XFRONT.XFE_E.NIN E_SENSE_CLK 2.60237f
C12 XRX.XCAP.O_QI XRX.XCAP.O_SET_TAIL 0.48793f
C13 VDD E_CAPTURE_CLKB 10.4775f
C14 XRX.XFRONT.XFE_E.H VDD 16.7985f
C15 TERM_EN5_N TERM_EN4_N 0.0465f
C16 XRX.XFRONT.XFE_O.NIN O_SENSE_CLK 2.60237f
C17 REST_BIAS RX_RAWP 0.25868f
C18 VDD FE_O_P 7.92276f
C19 VDD EVEN_Q 7.31561f
C20 XRX.XCAP.EVEN_DB_BUF XRX.XCAP.E_RST_TAIL 0.50524f
C21 XRX.XCAP.ODD_DB_BUF XRX.XCAP.O_SET_TAIL 0.54226f
C22 XRX.XFRONT.XFE_E.HB VDD 16.1006f
C23 XRX.XFRONT.XFE_O.NTAIL O_SENSE_BOOST 5.37348f
C24 XRX.XFRONT.XFE_O.NIP O_SENSE_CLK 2.64521f
C25 SAMP_E_N RX_RESTN 0.21698f
C26 PI_BUF_BIAS PI_CTRL_B 0.13433f
C27 XRX.XCAP.E_PRST_TAIL E_CAPTURE_CLKB 0.94605f
C28 XRX.XCAP.E_QI XRX.XCAP.E_RST_TAIL 4.88428f
C29 XRX.XCAP.O_QI XRX.XCAP.O_PSET_TAIL 5.10737f
C30 XRX.XFRONT.XFE_O.XP VDD 25.819f
C31 E_CAPTURE_CLKB E_CAPTURE_CLK 2.90103f
C32 RX_BIAS RXP 0.89265f
C33 SAMP_E_P E_SENSE_BOOST 0.11172f
C34 FE_O_N O_REGEN_CLKB 0.02948f
C35 XRX.XCAP.E_QBI E_CAPTURE_CLKB 0.12357f
C36 O_CAPTURE_CLKB O_CAPTURE_CLK 3.07425f
C37 XRX.XFRONT.XFE_E.H E_SENSE_CLK 1.23646f
C38 XRX.XCAP.EVEN_DB_BUF XRX.XCAP.E_SET_TAIL 0.71109f
C39 XRX.XCAP.ODD_DB_BUF XRX.XCAP.O_PSET_TAIL 0.68175f
C40 XRX.XCAP.O_PSET_TAIL ODD_QB 0.21495f
C41 XRX.XFRONT.XFE_O.XN VDD 25.3962f
C42 XRX.XCAP.ODD_D_BUF O_CAPTURE_CLK 0.0367f
C43 RX_RESTN RX_RESTP 4.19071f
C44 PI_RAW_P PI_RAW_N 1.04714f
C45 PI_CLK_N SAMP_BIAS 1.47664f
C46 XRX.XFRONT.XFE_E.HB E_SENSE_CLK 2.31435f
C47 XRX.XCAP.E_QI XRX.XCAP.E_SET_TAIL 0.76857f
C48 XRX.XFRONT.XFE_E.XN VDD 25.3962f
C49 XRX.XFRONT.XFE_O.H SAMP_O_N 0.01013f
C50 SAMP_E_N RX_RESTP 0.17266f
C51 XRX.XFRONT.XFE_O.HB O_SENSE_CLK 2.31435f
C52 XRX.XCAP.ODD_D_BUF FE_O_P 0.02446f
C53 XRX.XCAP.EVEN_D_BUF E_CAPTURE_CLKB 0.42228f
C54 XRX.XCAP.EVEN_DB_BUF XRX.XCAP.E_PSET_TAIL 1.81361f
C55 XRX.XCAP.ODD_DB_BUF XRX.XCAP.O_QI 3.71826f
C56 XRX.XCAP.O_QI ODD_QB 0.23682f
C57 XRX.XFRONT.XFE_E.XP VDD 25.819f
C58 VDD TERM_EN6_N 1.78028f
C59 XRX.XFRONT.XFE_O.H O_SENSE_CLK 1.23646f
C60 E_CAPTURE_CLKB FE_E_N 0.12139f
C61 XRX.XFRONT.XFE_E.H FE_E_N 1.28169f
C62 XRX.XCAP.E_QI XRX.XCAP.E_PSET_TAIL 5.13429f
C63 XRX.XCAP.O_QBI XRX.XCAP.O_RST_TAIL 0.0736f
C64 FE_O_N O_REGEN_CLK 0.01097f
C65 XRX.XCAP.ODD_DB_BUF ODD_QB 0.17063f
C66 XRX.XFRONT.XFE_E.NIN SAMP_E_P 2.30328f
C67 TERM_EN4_N TERM_EN3_N 0.0465f
C68 XRX.XFRONT.XFE_E.XN E_SENSE_CLK 5.09008f
C69 XRX.XCAP.O_QBUF XRX.XCAP.O_PSET_TAIL 0.04525f
C70 VDD REST_BIAS 0.20996f
C71 XRX.XCAP.EVEN_DB_BUF FE_E_P 3.50536f
C72 XRX.XFRONT.XFE_O.NIN O_SENSE_BOOST 0.0301f
C73 SAMP_O_P RX_RESTN 0.17429f
C74 XRX.XCAP.O_QBI XRX.XCAP.O_SET_TAIL 4.91815f
C75 XRX.XCAP.O_QBBUF XRX.XCAP.O_QI 0.68141f
C76 XRX.XFRONT.XFE_E.XP E_SENSE_CLK 5.70356f
C77 PHASE_A_P PI_CTRL_A 0.14136f
C78 XRX.XCAP.E_QI FE_E_P 0.09054f
C79 XRX.XFRONT.XFE_O.NIP O_SENSE_BOOST 0.21857f
C80 XRX.XFRONT.XFE_O.XP O_SENSE_CLK 5.70356f
C81 RX_RESTP PI_CLK_P 0.38527f
C82 VDD TERM_EN5_N 1.84084f
C83 XRX.XCAP.E_QI XRX.XCAP.EVEN_DB_BUF 3.57751f
C84 XRX.XCAP.O_QBBUF ODD_QB 0.15023f
C85 XRX.XFRONT.XFE_O.NIN XRX.XFRONT.XFE_O.NTAIL 10.6347f
C86 XRX.XFRONT.XFE_E.NTAIL E_SENSE_BOOST 5.37348f
C87 XRX.XFRONT.XFE_O.XN O_SENSE_CLK 5.09008f
C88 XRX.XCAP.E_RST_TAIL E_CAPTURE_CLK 1.16209f
C89 XRX.XFRONT.XFE_E.H SAMP_E_P 0.01013f
C90 XRX.XCAP.ODD_D_BUF XRX.XCAP.O_RST_TAIL 0.70292f
C91 XRX.XCAP.O_QBI XRX.XCAP.O_PSET_TAIL 0.30508f
C92 VDD PI_RAW_P 0.11594f
C93 XRX.XCAP.E_QBI XRX.XCAP.E_RST_TAIL 0.01355f
C94 XRX.XCAP.O_PSET_TAIL VDD 13.1964f
C95 XRX.XCAP.O_QBUF ODD_QB 4.17728f
C96 XRX.XFRONT.XFE_O.NIP XRX.XFRONT.XFE_O.NTAIL 10.1886f
C97 E_CAPTURE_CLKB EVEN_QB 0.70057f
C98 SAMP_O_P RX_RESTP 0.10098f
C99 VDD RX_RESTN 0.41275f
C100 RXP TERM_EN6_N 0.32905f
C101 EVEN_Q EVEN_QB 0.47433f
C102 XRX.XCAP.O_PRST_TAIL XRX.XCAP.O_PSET_TAIL 1.05443f
C103 XRX.XCAP.E_PSET_TAIL VDD 11.6748f
C104 XRX.XCAP.E_SET_TAIL E_CAPTURE_CLK 1.75694f
C105 VDD SAMP_E_N 0.26142f
C106 VDD TERM_EN4_N 1.84084f
C107 XRX.XCAP.ODD_D_BUF XRX.XCAP.O_SET_TAIL 0.53742f
C108 XRX.XCAP.E_QBI XRX.XCAP.E_SET_TAIL 4.91367f
C109 XRX.XCAP.O_QBI XRX.XCAP.O_QI 8.49253f
C110 XRX.XCAP.EVEN_D_BUF XRX.XCAP.E_RST_TAIL 0.37995f
C111 PHASE_B_P PI_CTRL_A 0.14849f
C112 XRX.XFRONT.XFE_E.NIP XRX.XFRONT.XFE_E.NTAIL 10.1886f
C113 XRX.XCAP.O_QI VDD 7.2336f
C114 XRX.XCAP.E_RST_TAIL FE_E_N 0.046f
C115 XRX.XFRONT.XFE_O.HB FE_O_N 1.39766f
C116 XRX.XCAP.E_PRST_TAIL XRX.XCAP.E_PSET_TAIL 1.95856f
C117 XRX.XCAP.O_QBI XRX.XCAP.ODD_DB_BUF 0.19065f
C118 XRX.XCAP.O_PRST_TAIL XRX.XCAP.O_QI 0.29363f
C119 XRX.XCAP.E_QBUF XRX.XCAP.E_QI 0.06057f
C120 VDD RX_RESTP 0.38423f
C121 XRX.XCAP.ODD_DB_BUF VDD 13.0218f
C122 XRX.XCAP.O_QBI ODD_QB 0.15666f
C123 XRX.XFRONT.XFE_E.NIN XRX.XFRONT.XFE_E.NTAIL 10.6347f
C124 VDD FE_E_P 8.10688f
C125 VDD ODD_QB 7.42733f
C126 TERM_EN3_N TERM_EN2_N 0.0465f
C127 VDD RX_RAWP 1.26797f
C128 VDD PI_RAW_N 0.04221f
C129 XRX.XCAP.O_PSET_TAIL O_CAPTURE_CLKB 2.02608f
C130 O_CAPTURE_CLK O_REGEN_CLKB 0.0323f
C131 XRX.XCAP.ODD_D_BUF XRX.XCAP.O_PSET_TAIL 1.09217f
C132 XRX.XCAP.O_PRST_TAIL XRX.XCAP.ODD_DB_BUF 0.86137f
C133 XRX.XCAP.E_QBBUF XRX.XCAP.E_QI 0.60128f
C134 XRX.XCAP.E_QBI XRX.XCAP.E_PSET_TAIL 0.20078f
C135 XRX.XCAP.EVEN_D_BUF XRX.XCAP.E_SET_TAIL 0.61506f
C136 FE_O_N O_CAPTURE_CLK 0.52074f
C137 XRX.XCAP.O_PRST_TAIL ODD_QB 0.43511f
C138 RXP TERM_EN5_N 0.3225f
C139 XRX.XCAP.EVEN_DB_BUF VDD 12.9418f
C140 E_SENSE_CLK SAMP_E_N 0.40197f
C141 XRX.XCAP.E_QI VDD 7.23216f
C142 XRX.XFRONT.XFE_O.HB XRX.XFRONT.XFE_O.DN 2.12721f
C143 VDD TERM_EN3_N 1.84084f
C144 FE_E_P E_CAPTURE_CLK 0.45212f
C145 FE_O_P FE_O_N 2.27142f
C146 RX_BIAS RXN 0.36689f
C147 SAMP_O_N RX_RESTN 0.01966f
C148 VDD PI_CLK_P 0.76876f
C149 XRX.XCAP.O_QI O_CAPTURE_CLKB 0.15737f
C150 XRX.XCAP.ODD_D_BUF XRX.XCAP.O_QI 0.70423f
C151 XRX.XCAP.EVEN_D_BUF XRX.XCAP.E_PSET_TAIL 0.4182f
C152 XRX.XCAP.E_PRST_TAIL XRX.XCAP.EVEN_DB_BUF 0.13174f
C153 PHASE_B_N PI_CTRL_A 0.01829f
C154 XRX.XFRONT.XFE_O.H XRX.XFRONT.XFE_O.DN 0.66623f
C155 XRX.XFRONT.XFE_O.HB XRX.XFRONT.XFE_O.DP 0.75819f
C156 XRX.XCAP.O_QBBUF VDD 6.75866f
C157 XRX.XFRONT.XFE_E.NIP E_SENSE_BOOST 0.21857f
C158 XRX.XCAP.EVEN_DB_BUF E_CAPTURE_CLK 0.15269f
C159 RX_RESTN SAMP_BIAS 0.01215f
C160 XRX.XCAP.ODD_DB_BUF O_CAPTURE_CLKB 0.81461f
C161 O_CAPTURE_CLKB ODD_QB 0.10357f
C162 XRX.XCAP.E_PRST_TAIL XRX.XCAP.E_QI 0.2741f
C163 XRX.XCAP.ODD_D_BUF XRX.XCAP.ODD_DB_BUF 1.07149f
C164 XRX.XCAP.O_QBI XRX.XCAP.O_QBUF 1.08164f
C165 XRX.XCAP.E_QBI XRX.XCAP.EVEN_DB_BUF 0.0643f
C166 XRX.XCAP.ODD_D_BUF ODD_QB 0.15391f
C167 XRX.XCAP.O_QBUF VDD 6.35692f
C168 XRX.XFRONT.XFE_O.H XRX.XFRONT.XFE_O.DP 2.1383f
C169 XRX.XFRONT.XFE_E.NIN E_SENSE_BOOST 0.0301f
C170 O_CAPTURE_CLK O_REGEN_CLK 0.01576f
C171 XRX.XCAP.E_QI E_CAPTURE_CLK 0.1853f
C172 VDD SAMP_O_P 0.35499f
C173 RXP TERM_EN4_N 0.3225f
C174 RX_RAWP RX_BW_EN_N 0.3734f
C175 XRX.XCAP.E_QBI XRX.XCAP.E_QI 8.54354f
C176 XRX.XCAP.O_PRST_TAIL XRX.XCAP.O_QBUF 1.54979f
C177 XRX.XCAP.EVEN_D_BUF FE_E_P 0.04189f
C178 XRX.XCAP.E_QBUF VDD 7.45153f
C179 SAMP_O_N RX_RESTP 0.21629f
C180 PHASE_A_P PHASE_B_P 0.41197f
C181 VDD TERM_EN2_N 1.84084f
C182 FE_E_N FE_E_P 3.5147f
C183 XRX.XCAP.EVEN_D_BUF XRX.XCAP.EVEN_DB_BUF 0.97829f
C184 CLK_REST_BIAS PI_RAW_P 0.13683f
C185 XRX.XFRONT.XFE_O.HB XRX.XFRONT.XFE_O.NIN 0.07207f
C186 XRX.XFRONT.XFE_E.H XRX.XFRONT.XFE_E.DP 2.1383f
C187 XRX.XFRONT.XFE_O.XP XRX.XFRONT.XFE_O.DN 0.04432f
C188 XRX.XCAP.E_QBBUF VDD 6.44257f
C189 XRX.XCAP.EVEN_DB_BUF FE_E_N 0.03785f
C190 XRX.XCAP.O_QBBUF O_CAPTURE_CLKB 0.16758f
C191 SAMP_E_P RX_RESTN 0.42621f
C192 TERM_EN2_N TERM_EN1_N 0.0465f
C193 XRX.XCAP.EVEN_D_BUF XRX.XCAP.E_QI 0.74882f
C194 XRX.XCAP.E_PRST_TAIL XRX.XCAP.E_QBUF 0.53754f
C195 XRX.XCAP.ODD_D_BUF XRX.XCAP.O_QBBUF 2.37715f
C196 XRX.XFRONT.XFE_E.H XRX.XFRONT.XFE_E.DN 0.66623f
C197 XRX.XFRONT.XFE_E.HB XRX.XFRONT.XFE_E.DP 0.75819f
C198 XRX.XFRONT.XFE_O.XP XRX.XFRONT.XFE_O.DP 2.21809f
C199 XRX.XFRONT.XFE_O.XN XRX.XFRONT.XFE_O.DN 2.15469f
C200 XRX.XCAP.O_QBI VDD 8.61871f
C201 XRX.XFRONT.XFE_O.H XRX.XFRONT.XFE_O.NIN 0.07808f
C202 XRX.XFRONT.XFE_O.HB XRX.XFRONT.XFE_O.NIP 0.07069f
C203 XRX.XCAP.E_QI FE_E_N 0.52886f
C204 RXP TERM_EN3_N 0.3225f
C205 SAMP_E_P SAMP_E_N 11.0925f
C206 XRX.XCAP.E_QBI XRX.XCAP.E_QBUF 0.99299f
C207 XRX.XCAP.O_PRST_TAIL XRX.XCAP.O_QBI 5.53402f
C208 XRX.XCAP.ODD_D_BUF XRX.XCAP.O_QBUF 0.28842f
C209 XRX.XCAP.O_PRST_TAIL VDD 15.3528f
C210 XRX.XFRONT.XFE_E.HB XRX.XFRONT.XFE_E.DN 2.12721f
C211 XRX.XFRONT.XFE_O.H XRX.XFRONT.XFE_O.NIP 0.07683f
C212 FE_E_P E_REGEN_CLKB 0.02948f
C213 XRX.XCAP.E_PSET_TAIL EVEN_QB 0.02064f
C214 PI_CLK_P SAMP_BIAS 2.0425f
C215 VDD TERM_EN1_N 1.84084f
C216 XRX.XCAP.E_PRST_TAIL VDD 16.0686f
C217 VDD E_CAPTURE_CLK 2.33005f
C218 SAMP_E_P RX_RESTP 0.05468f
C219 SAMP_O_P SAMP_O_N 11.1662f
C220 CLK_REST_BIAS PI_RAW_N 0.11403f
C221 VDD E_SENSE_CLK 21.2686f
C222 XRX.XFRONT.XFE_O.XP XRX.XFRONT.XFE_O.NIN 2.21087f
C223 XRX.XFRONT.XFE_E.H XRX.XFRONT.XFE_E.NIP 0.07683f
C224 XRX.XCAP.E_QBI VDD 8.57345f
C225 EVEN_QB FE_E_P 0.07547f
C226 O_SENSE_CLK SAMP_O_P 0.40197f
C227 XRX.XCAP.O_QBI O_CAPTURE_CLKB 0.07731f
C228 VDD O_CAPTURE_CLKB 10.3129f
C229 XRX.XCAP.ODD_D_BUF XRX.XCAP.O_QBI 4.78972f
C230 XRX.XCAP.EVEN_D_BUF XRX.XCAP.E_QBBUF 2.27875f
C231 RXP TERM_EN2_N 0.3225f
C232 XRX.XFRONT.XFE_O.H XRX.XFRONT.XFE_O.HB 7.51355f
C233 XRX.XFRONT.XFE_E.XN XRX.XFRONT.XFE_E.DN 2.15469f
C234 XRX.XFRONT.XFE_E.HB XRX.XFRONT.XFE_E.NIP 0.07069f
C235 XRX.XFRONT.XFE_O.XP XRX.XFRONT.XFE_O.NIP 14.4614f
C236 XRX.XFRONT.XFE_O.XN XRX.XFRONT.XFE_O.NIN 14.5465f
C237 XRX.XFRONT.XFE_E.H XRX.XFRONT.XFE_E.NIN 0.07808f
C238 XRX.XFRONT.XFE_E.XP XRX.XFRONT.XFE_E.DP 2.21809f
C239 XRX.XCAP.ODD_D_BUF VDD 15.601f
C240 VDD RX_BW_EN_N 3.19847f
C241 XRX.XCAP.EVEN_DB_BUF EVEN_QB 0.15519f
C242 FE_E_P E_REGEN_CLK 0.01097f
C243 XRX.XCAP.E_QBBUF FE_E_N 0.14911f
C244 XRX.XCAP.O_PRST_TAIL O_CAPTURE_CLKB 3.41065f
C245 XRX.XCAP.ODD_D_BUF XRX.XCAP.O_PRST_TAIL 0.78807f
C246 XRX.XCAP.E_QBI XRX.XCAP.E_PRST_TAIL 5.5293f
C247 XRX.XFRONT.XFE_E.HB XRX.XFRONT.XFE_E.NIN 0.07207f
C248 XRX.XFRONT.XFE_O.XN XRX.XFRONT.XFE_O.NIP 2.86849f
C249 XRX.XFRONT.XFE_E.XP XRX.XFRONT.XFE_E.DN 0.04432f
C250 VDD TERM_EN0_N 1.71963f
C251 XRX.XCAP.EVEN_D_BUF VDD 14.4594f
C252 XRX.XCAP.E_QI EVEN_QB 0.33632f
C253 VDD SAMP_O_N 0.35499f
C254 VDD FE_E_N 7.89923f
C255 VDD RXP 0.72204f
C256 PHASE_B_P PHASE_B_N 0.27529f
C257 VDD O_SENSE_CLK 21.2686f
C258 PI_CTRL_A PI_CTRL_B 0.01148f
C259 XRX.XFRONT.XFE_O.H FE_O_P 1.28169f
C260 TERM_EN1_N TERM_EN0_N 0.0465f
C261 FE_O_P O_CAPTURE_CLK 0.2426f
C262 XRX.XCAP.O_QI FE_O_N 0.57789f
C263 XRX.XCAP.EVEN_D_BUF XRX.XCAP.E_PRST_TAIL 3.77728f
C264 XRX.XFRONT.XFE_O.XP XRX.XFRONT.XFE_O.HB 3.58406f
C265 XRX.XFRONT.XFE_E.XN XRX.XFRONT.XFE_E.NIP 2.86849f
C266 VDD VTHP 0.93005f
C267 XRX.XCAP.EVEN_D_BUF E_CAPTURE_CLK 0.10379f
C268 RXP TERM_EN1_N 0.30522f
C269 XRX.XFRONT.XFE_E.NTAIL SAMP_E_N 2.27268f
C270 E_CAPTURE_CLKB EVEN_Q 0.10117f
C271 XRX.XCAP.ODD_D_BUF O_CAPTURE_CLKB 0.70031f
C272 FE_E_N E_CAPTURE_CLK 0.57071f
C273 XRX.XCAP.EVEN_D_BUF XRX.XCAP.E_QBI 4.77076f
C274 ODD_QB FE_O_N 0.09326f
C275 XRX.XFRONT.XFE_E.XN XRX.XFRONT.XFE_E.NIN 14.5465f
C276 XRX.XFRONT.XFE_E.HB XRX.XFRONT.XFE_E.H 7.51355f
C277 XRX.XFRONT.XFE_E.XP XRX.XFRONT.XFE_E.NIP 14.4614f
C278 XRX.XFRONT.XFE_O.XP XRX.XFRONT.XFE_O.H 0.82467f
C279 XRX.XFRONT.XFE_O.XN XRX.XFRONT.XFE_O.HB 0.56886f
C280 VDD E_REGEN_CLKB 0.12239f
C281 XRX.XCAP.E_QBUF EVEN_QB 4.13702f
C282 XRX.XFRONT.XFE_E.XP XRX.XFRONT.XFE_E.NIN 2.21087f
C283 XRX.XFRONT.XFE_O.XN XRX.XFRONT.XFE_O.H 1.91259f
C284 REST_BIAS RX_RAWN 0.11711f
C285 VDD CLK_REST_BIAS 0.20024f
C286 XRX.XCAP.E_QBBUF EVEN_QB 0.17621f
C287 VDD SAMP_E_P 0.26142f
C288 SAMP_O_P O_SENSE_BOOST 0.07703f
C289 VDD EVEN_QB 8.86516f
C290 E_CAPTURE_CLK E_REGEN_CLKB 0.0323f
C291 XRX.XCAP.EVEN_D_BUF FE_E_N 3.45509f
C292 RXP TERM_EN0_N 0.29398f
C293 XRX.XCAP.O_QBBUF FE_O_N 0.20592f
C294 XRX.XFRONT.XFE_E.XN XRX.XFRONT.XFE_E.H 1.91259f
C295 RX_BW_EN_N VTHP 0.14804f
C296 SAMP_E_N E_SENSE_BOOST 0.07703f
C297 O_SENSE_CLK SAMP_O_N 5.56072f
C298 VDD E_REGEN_CLK 0.13137f
C299 XRX.XFRONT.XFE_E.XN XRX.XFRONT.XFE_E.HB 0.56886f
C300 XRX.XFRONT.XFE_O.XN XRX.XFRONT.XFE_O.XP 22.8576f
C301 XRX.XFRONT.XFE_E.XP XRX.XFRONT.XFE_E.H 0.82467f
C302 XRX.XCAP.O_RST_TAIL O_CAPTURE_CLK 2.06628f
C303 XRX.XCAP.E_PRST_TAIL EVEN_QB 0.0844f
C304 XRX.XFRONT.XFE_O.NTAIL SAMP_O_P 2.27268f
C305 E_SENSE_CLK SAMP_E_P 5.56072f
C306 XRX.XFRONT.XFE_E.XP XRX.XFRONT.XFE_E.HB 3.58406f
C307 XRX.XCAP.E_QBI EVEN_QB 0.15538f
C308 XRX.XCAP.O_RST_TAIL FE_O_P 0.16401f
C309 E_CAPTURE_CLK E_REGEN_CLK 0.01576f
C310 PHASE_B_N PHASE_A_N 0.41197f
C311 XRX.XCAP.O_SET_TAIL O_CAPTURE_CLK 1.51208f
C312 XRX.XFRONT.XFE_E.NIP SAMP_E_N 1.58284f
C313 RX_RESTN PI_CLK_N 0.09294f
C314 VDD O_REGEN_CLKB 0.12239f
C315 VDD FE_O_N 8.03479f
C316 XRX.XCAP.EVEN_D_BUF EVEN_QB 0.13958f
C317 VDD VTHN 0.51765f
C318 RX_RAWP RX_RAWN 0.58235f
C319 EVEN_QB FE_E_N 0.06902f
C320 ODD_QB ODD_Q 0.51937f
C321 XRX.XFRONT.XFE_E.XP XRX.XFRONT.XFE_E.XN 22.8576f
C322 PHASE_B_P PI_CTRL_B 0.02033f
C323 XRX.XFRONT.XFE_O.DN VDD 6.18388f
C324 RX_RESTP PI_CLK_N 0.02351f
C325 XRX.XCAP.E_PSET_TAIL E_CAPTURE_CLKB 3.32426f
C326 XRX.XFRONT.XFE_O.DP VDD 6.18171f
C327 XRX.XCAP.O_QI O_CAPTURE_CLK 0.16467f
C328 VDD O_REGEN_CLK 0.13137f
C329 XRX.XFRONT.XFE_E.H SAMP_E_N 0.01013f
C330 SAMP_O_N O_SENSE_BOOST 0.11172f
C331 O_CAPTURE_CLKB FE_O_N 0.16306f
C332 XRX.XCAP.O_QBBUF ODD_Q 4.18276f
C333 XRX.XCAP.ODD_D_BUF FE_O_N 3.44145f
C334 XRX.XFRONT.XFE_E.NTAIL E_SENSE_CLK 1.32172f
C335 XRX.XCAP.ODD_DB_BUF O_CAPTURE_CLK 0.32291f
C336 XRX.XFRONT.XFE_E.DP VDD 6.18171f
C337 XRX.XFRONT.XFE_O.NIP SAMP_O_P 1.58284f
C338 RX_BW_EN_N VTHN 0.52758f
C339 O_SENSE_CLK O_SENSE_BOOST 6.47808f
C340 XRX.XCAP.O_QI FE_O_P 0.12934f
C341 PI_CLK_P PI_CLK_N 9.08661f
C342 E_CAPTURE_CLKB FE_E_P 0.28348f
C343 XRX.XFRONT.XFE_E.DN VDD 6.18388f
C344 XRX.XFRONT.XFE_O.NTAIL SAMP_O_N 1.55309f
C345 XRX.XCAP.ODD_DB_BUF FE_O_P 3.64424f
C346 TERM_EN6_N TERM_EN5_N 0.0465f
C347 ODD_QB FE_O_P 0.10247f
C348 PHASE_B_N PI_CTRL_B 0.1441f
C349 XRX.XCAP.EVEN_DB_BUF E_CAPTURE_CLKB 0.19022f
C350 XRX.XCAP.O_SET_TAIL XRX.XCAP.O_RST_TAIL 0.70351f
C351 XRX.XFRONT.XFE_E.HB FE_E_P 1.39766f
C352 XRX.XFRONT.XFE_O.NIN VDD 6.7829f
C353 XRX.XFRONT.XFE_O.NTAIL O_SENSE_CLK 1.32172f
C354 XRX.XCAP.E_QI E_CAPTURE_CLKB 0.15555f
C355 XRX.XFRONT.XFE_E.DP E_SENSE_CLK 0.29923f
C356 XRX.XFRONT.XFE_O.NIP VDD 6.70406f
C357 VTHP VTHN 1.695f
C358 VDD RX_RAWN 1.26797f
C359 VDD ODD_Q 7.41927f
C360 XRX.XFRONT.XFE_E.DN E_SENSE_CLK 0.18071f
C361 XRX.XCAP.E_SET_TAIL XRX.XCAP.E_RST_TAIL 0.57545f
C362 E_SENSE_CLK E_SENSE_BOOST 6.47808f
C363 XRX.XFRONT.XFE_E.NIP VDD 6.70406f
C364 XRX.XFRONT.XFE_O.H SAMP_O_P 0.01013f
C365 XRX.XFRONT.XFE_O.DN O_SENSE_CLK 0.18071f
C366 XRX.XFRONT.XFE_E.NIN VDD 6.7829f
C367 XRX.XFRONT.XFE_O.DP O_SENSE_CLK 0.29923f
C368 VDD PI_CLK_N 1.06379f
C369 RXP RXN 0.49155f
C370 PHASE_A_N PI_CTRL_B 0.13686f
C371 XRX.XCAP.O_QI XRX.XCAP.O_RST_TAIL 4.94403f
C372 XRX.XFRONT.XFE_O.HB VDD 16.1006f
C373 O_REGEN_CLK VSS 0.09722f
C374 O_REGEN_CLKB VSS 0.08114f
C375 E_REGEN_CLK VSS 0.09722f
C376 E_REGEN_CLKB VSS 0.08114f
C377 TERM_EN0_N VSS 3.16281f
C378 TERM_EN1_N VSS 2.58106f
C379 TERM_EN2_N VSS 2.56583f
C380 TERM_EN3_N VSS 2.56561f
C381 TERM_EN4_N VSS 2.56561f
C382 TERM_EN5_N VSS 2.56561f
C383 TERM_EN6_N VSS 2.69513f
C384 RXN VSS 15.24638f
C385 RXP VSS 15.17772f
C386 RX_BIAS VSS 13.3368f
C387 VTHN VSS 5.17466f
C388 VTHP VSS 5.04058f
C389 RX_BW_EN_N VSS 4.30524f
C390 RX_RAWN VSS 11.07534f
C391 RX_RAWP VSS 11.20287f
C392 PI_CTRL_B VSS 4.65024f
C393 PI_CTRL_A VSS 3.45407f
C394 PI_BUF_BIAS VSS 2.78969f
C395 PHASE_A_N VSS 2.73702f
C396 PHASE_B_N VSS 2.92306f
C397 PHASE_B_P VSS 2.86471f
C398 PHASE_A_P VSS 2.8479f
C399 PI_RAW_N VSS 21.74305f
C400 PI_RAW_P VSS 18.58269f
C401 REST_BIAS VSS 10.07665f
C402 CLK_REST_BIAS VSS 6.04268f
C403 SAMP_BIAS VSS 13.87178f
C404 PI_CLK_N VSS 33.96273f
C405 PI_CLK_P VSS 34.31174f
C406 RX_RESTP VSS 14.02047f
C407 RX_RESTN VSS 13.0766f
C408 O_SENSE_BOOST VSS 19.06934f
C409 SAMP_O_N VSS 17.84324f
C410 SAMP_O_P VSS 25.01242f
C411 E_SENSE_BOOST VSS 19.06934f
C412 SAMP_E_N VSS 24.79697f
C413 SAMP_E_P VSS 17.83336f
C414 O_SENSE_CLK VSS 17.6524f
C415 E_SENSE_CLK VSS 17.6524f
C416 O_CAPTURE_CLK VSS 27.66099f
C417 E_CAPTURE_CLK VSS 26.7743f
C418 FE_O_N VSS 27.96589f
C419 FE_O_P VSS 32.50097f
C420 FE_E_P VSS 35.08967f
C421 FE_E_N VSS 26.68814f
C422 ODD_Q VSS 5.29541f
C423 ODD_QB VSS 9.73643f
C424 EVEN_QB VSS 9.40271f
C425 EVEN_Q VSS 5.60206f
C426 O_CAPTURE_CLKB VSS 24.58528f
C427 E_CAPTURE_CLKB VSS 27.1212f
C428 VDD VSS 4.72827p
C429 XRX.XFRONT.XFE_O.NTAIL VSS 46.98668f
C430 XRX.XFRONT.XFE_E.NTAIL VSS 47.47016f
C431 XRX.XFRONT.XFE_O.DN VSS 9.84723f
C432 XRX.XFRONT.XFE_O.DP VSS 9.85739f
C433 XRX.XFRONT.XFE_E.DP VSS 10.10227f
C434 XRX.XFRONT.XFE_E.DN VSS 10.19211f
C435 XRX.XFRONT.XFE_O.NIN VSS 3.76356f
C436 XRX.XFRONT.XFE_O.NIP VSS 3.47617f
C437 XRX.XFRONT.XFE_E.NIP VSS 4.35051f
C438 XRX.XFRONT.XFE_E.NIN VSS 5.165f
C439 XRX.XFRONT.XFE_O.HB VSS 19.64067f
C440 XRX.XFRONT.XFE_O.H VSS 20.30146f
C441 XRX.XFRONT.XFE_E.H VSS 20.61385f
C442 XRX.XFRONT.XFE_E.HB VSS 20.35346f
C443 XRX.XFRONT.XFE_O.XP VSS 10.75778f
C444 XRX.XFRONT.XFE_O.XN VSS 11.15447f
C445 XRX.XFRONT.XFE_E.XN VSS 13.06891f
C446 XRX.XFRONT.XFE_E.XP VSS 12.33217f
C447 XRX.XCAP.O_RST_TAIL VSS 14.07771f
C448 XRX.XCAP.E_RST_TAIL VSS 13.39814f
C449 XRX.XCAP.O_SET_TAIL VSS 11.53561f
C450 XRX.XCAP.E_SET_TAIL VSS 11.52819f
C451 XRX.XCAP.O_PSET_TAIL VSS 0.23222f
C452 XRX.XCAP.E_PSET_TAIL VSS 0.15708f
C453 XRX.XCAP.O_QI VSS 12.92219f
C454 XRX.XCAP.ODD_DB_BUF VSS 9.95341f
C455 XRX.XCAP.EVEN_DB_BUF VSS 10.21407f
C456 XRX.XCAP.E_QI VSS 12.05735f
C457 XRX.XCAP.O_QBBUF VSS 5.49643f
C458 XRX.XCAP.O_QBUF VSS 5.2576f
C459 XRX.XCAP.E_QBUF VSS 5.25384f
C460 XRX.XCAP.E_QBBUF VSS 6.1426f
C461 XRX.XCAP.O_QBI VSS 10.93681f
C462 XRX.XCAP.O_PRST_TAIL VSS 0.25427f
C463 XRX.XCAP.E_PRST_TAIL VSS 0.70236f
C464 XRX.XCAP.E_QBI VSS 11.57233f
C465 XRX.XCAP.ODD_D_BUF VSS 9.0285f
C466 XRX.XCAP.EVEN_D_BUF VSS 9.21535f
C467 XRX.XCAP.EVEN_D_BUF.n0 VSS 0.33788f
C468 XRX.XCAP.EVEN_D_BUF.n1 VSS 0.16701f
C469 XRX.XCAP.EVEN_D_BUF.n2 VSS 0.17902f
C470 XRX.XCAP.EVEN_D_BUF.n3 VSS 0.17902f
C471 XRX.XCAP.EVEN_D_BUF.n4 VSS 0.16919f
C472 XRX.XCAP.EVEN_D_BUF.n5 VSS 2.35913f
C473 XRX.XCAP.EVEN_D_BUF.n6 VSS 0.33788f
C474 XRX.XCAP.EVEN_D_BUF.n7 VSS 0.16701f
C475 XRX.XCAP.EVEN_D_BUF.n8 VSS 0.17902f
C476 XRX.XCAP.EVEN_D_BUF.n9 VSS 0.17902f
C477 XRX.XCAP.EVEN_D_BUF.n10 VSS 0.16919f
C478 XRX.XCAP.EVEN_D_BUF.n11 VSS 1.74907f
C479 XRX.XCAP.EVEN_D_BUF.n12 VSS 6.49511f
C480 XRX.XCAP.EVEN_D_BUF.t11 VSS 1.36064f
C481 XRX.XCAP.EVEN_D_BUF.t10 VSS 0.26004f
C482 XRX.XCAP.EVEN_D_BUF.t9 VSS 0.26004f
C483 XRX.XCAP.EVEN_D_BUF.n13 VSS 1.05804f
C484 XRX.XCAP.EVEN_D_BUF.n14 VSS 0.58157f
C485 XRX.XCAP.EVEN_D_BUF.t8 VSS 0.26004f
C486 XRX.XCAP.EVEN_D_BUF.t7 VSS 0.26004f
C487 XRX.XCAP.EVEN_D_BUF.n15 VSS 1.05804f
C488 XRX.XCAP.EVEN_D_BUF.n16 VSS 0.24385f
C489 XRX.XCAP.EVEN_D_BUF.t4 VSS 1.36064f
C490 XRX.XCAP.EVEN_D_BUF.t6 VSS 0.26004f
C491 XRX.XCAP.EVEN_D_BUF.t5 VSS 0.26004f
C492 XRX.XCAP.EVEN_D_BUF.n17 VSS 1.05804f
C493 XRX.XCAP.EVEN_D_BUF.n18 VSS 0.52182f
C494 XRX.XCAP.EVEN_D_BUF.n19 VSS 0.11987f
C495 XRX.XCAP.EVEN_D_BUF.t3 VSS 1.35812f
C496 XRX.XCAP.EVEN_D_BUF.t2 VSS 0.26004f
C497 XRX.XCAP.EVEN_D_BUF.t1 VSS 0.26004f
C498 XRX.XCAP.EVEN_D_BUF.n20 VSS 1.05024f
C499 XRX.XCAP.EVEN_D_BUF.n21 VSS 0.53215f
C500 XRX.XCAP.EVEN_D_BUF.t0 VSS 1.35244f
C501 XRX.XCAP.EVEN_D_BUF.n22 VSS 1.1256f
C502 XRX.XCAP.EVEN_D_BUF.n23 VSS 2.00092f
C503 XRX.XCAP.EVEN_D_BUF.n24 VSS 0.91313f
C504 XRX.XCAP.ODD_D_BUF.t3 VSS 1.32514f
C505 XRX.XCAP.ODD_D_BUF.t2 VSS 0.25208f
C506 XRX.XCAP.ODD_D_BUF.t1 VSS 0.25208f
C507 XRX.XCAP.ODD_D_BUF.n0 VSS 1.02634f
C508 XRX.XCAP.ODD_D_BUF.n1 VSS 0.52004f
C509 XRX.XCAP.ODD_D_BUF.t0 VSS 1.3196f
C510 XRX.XCAP.ODD_D_BUF.n2 VSS 1.10721f
C511 XRX.XCAP.ODD_D_BUF.t11 VSS 1.32761f
C512 XRX.XCAP.ODD_D_BUF.t10 VSS 0.25208f
C513 XRX.XCAP.ODD_D_BUF.t9 VSS 0.25208f
C514 XRX.XCAP.ODD_D_BUF.n3 VSS 1.03396f
C515 XRX.XCAP.ODD_D_BUF.n4 VSS 0.56834f
C516 XRX.XCAP.ODD_D_BUF.t8 VSS 0.25208f
C517 XRX.XCAP.ODD_D_BUF.t7 VSS 0.25208f
C518 XRX.XCAP.ODD_D_BUF.n5 VSS 1.03396f
C519 XRX.XCAP.ODD_D_BUF.n6 VSS 0.2383f
C520 XRX.XCAP.ODD_D_BUF.t4 VSS 1.32761f
C521 XRX.XCAP.ODD_D_BUF.t6 VSS 0.25208f
C522 XRX.XCAP.ODD_D_BUF.t5 VSS 0.25208f
C523 XRX.XCAP.ODD_D_BUF.n7 VSS 1.03396f
C524 XRX.XCAP.ODD_D_BUF.n8 VSS 0.50995f
C525 XRX.XCAP.ODD_D_BUF.n9 VSS 0.11678f
C526 XRX.XCAP.ODD_D_BUF.n10 VSS 2.49974f
C527 XRX.XCAP.ODD_D_BUF.n11 VSS 0.33019f
C528 XRX.XCAP.ODD_D_BUF.n12 VSS 0.16321f
C529 XRX.XCAP.ODD_D_BUF.n13 VSS 0.17494f
C530 XRX.XCAP.ODD_D_BUF.n14 VSS 0.17494f
C531 XRX.XCAP.ODD_D_BUF.n15 VSS 0.16534f
C532 XRX.XCAP.ODD_D_BUF.n16 VSS 1.68886f
C533 XRX.XCAP.ODD_D_BUF.n17 VSS 3.87043f
C534 XRX.XCAP.ODD_D_BUF.n18 VSS 0.33019f
C535 XRX.XCAP.ODD_D_BUF.n19 VSS 0.16321f
C536 XRX.XCAP.ODD_D_BUF.n20 VSS 0.17494f
C537 XRX.XCAP.ODD_D_BUF.n21 VSS 0.17494f
C538 XRX.XCAP.ODD_D_BUF.n22 VSS 0.16534f
C539 XRX.XCAP.ODD_D_BUF.n23 VSS 2.03803f
C540 XRX.XCAP.ODD_D_BUF.n24 VSS 3.5691f
C541 XRX.XCAP.E_QBI.n0 VSS 0.84803f
C542 XRX.XCAP.E_QBI.n1 VSS 0.44045f
C543 XRX.XCAP.E_QBI.n2 VSS 3.21925f
C544 XRX.XCAP.E_QBI.t7 VSS 1.3223f
C545 XRX.XCAP.E_QBI.t6 VSS 1.31385f
C546 XRX.XCAP.E_QBI.n3 VSS 1.04291f
C547 XRX.XCAP.E_QBI.t5 VSS 1.32006f
C548 XRX.XCAP.E_QBI.t4 VSS 1.31159f
C549 XRX.XCAP.E_QBI.n4 VSS 0.5077f
C550 XRX.XCAP.E_QBI.n5 VSS 1.57463f
C551 XRX.XCAP.E_QBI.t1 VSS 1.33522f
C552 XRX.XCAP.E_QBI.t8 VSS 0.35565f
C553 XRX.XCAP.E_QBI.t9 VSS 0.35565f
C554 XRX.XCAP.E_QBI.n6 VSS 0.9346f
C555 XRX.XCAP.E_QBI.n7 VSS 0.47356f
C556 XRX.XCAP.E_QBI.t2 VSS 1.32683f
C557 XRX.XCAP.E_QBI.n8 VSS 0.51261f
C558 XRX.XCAP.E_QBI.n9 VSS 0.96021f
C559 XRX.XCAP.E_QBI.n10 VSS 1.88012f
C560 XRX.XCAP.E_QBI.t3 VSS 1.33746f
C561 XRX.XCAP.E_QBI.t10 VSS 0.35565f
C562 XRX.XCAP.E_QBI.t11 VSS 0.35565f
C563 XRX.XCAP.E_QBI.n11 VSS 0.94155f
C564 XRX.XCAP.E_QBI.t0 VSS 1.33412f
C565 XRX.XCAP.E_QBI.n12 VSS 2.12356f
C566 XRX.XCAP.E_QBI.n13 VSS 0.42173f
C567 XRX.XCAP.E_QBI.n14 VSS 3.48843f
C568 XRX.XCAP.E_QBI.n15 VSS 0.44926f
C569 XRX.XCAP.E_QBI.n16 VSS 1.3761f
C570 XRX.XCAP.E_QBI.n17 VSS 0.45859f
C571 XRX.XCAP.E_PRST_TAIL.t2 VSS 1.66645f
C572 XRX.XCAP.E_PRST_TAIL.t4 VSS 0.31976f
C573 XRX.XCAP.E_PRST_TAIL.t3 VSS 0.31976f
C574 XRX.XCAP.E_PRST_TAIL.n0 VSS 1.29586f
C575 XRX.XCAP.E_PRST_TAIL.n1 VSS 0.71229f
C576 XRX.XCAP.E_PRST_TAIL.t6 VSS 0.31976f
C577 XRX.XCAP.E_PRST_TAIL.t5 VSS 0.31976f
C578 XRX.XCAP.E_PRST_TAIL.n2 VSS 1.29586f
C579 XRX.XCAP.E_PRST_TAIL.n3 VSS 0.37183f
C580 XRX.XCAP.E_PRST_TAIL.t8 VSS 0.31976f
C581 XRX.XCAP.E_PRST_TAIL.t7 VSS 0.31976f
C582 XRX.XCAP.E_PRST_TAIL.n4 VSS 1.29586f
C583 XRX.XCAP.E_PRST_TAIL.n5 VSS 0.37183f
C584 XRX.XCAP.E_PRST_TAIL.t9 VSS 1.65616f
C585 XRX.XCAP.E_PRST_TAIL.n6 VSS 5.16751f
C586 XRX.XCAP.E_PRST_TAIL.t1 VSS 0.42743f
C587 XRX.XCAP.E_PRST_TAIL.t10 VSS 0.4241f
C588 XRX.XCAP.E_PRST_TAIL.n7 VSS 1.30601f
C589 XRX.XCAP.E_PRST_TAIL.t11 VSS 0.4241f
C590 XRX.XCAP.E_PRST_TAIL.t0 VSS 0.4241f
C591 XRX.XCAP.E_PRST_TAIL.n8 VSS 1.29586f
C592 XRX.XCAP.E_PRST_TAIL.n9 VSS 3.3314f
C593 XRX.XCAP.E_PRST_TAIL.n10 VSS 7.14958f
C594 XRX.XCAP.O_PRST_TAIL.t0 VSS 0.45317f
C595 XRX.XCAP.O_PRST_TAIL.t10 VSS 0.45317f
C596 XRX.XCAP.O_PRST_TAIL.n0 VSS 1.47829f
C597 XRX.XCAP.O_PRST_TAIL.t11 VSS 0.45317f
C598 XRX.XCAP.O_PRST_TAIL.t9 VSS 0.45643f
C599 XRX.XCAP.O_PRST_TAIL.n1 VSS 1.4668f
C600 XRX.XCAP.O_PRST_TAIL.n2 VSS 3.90634f
C601 XRX.XCAP.O_PRST_TAIL.t8 VSS 1.88148f
C602 XRX.XCAP.O_PRST_TAIL.t7 VSS 0.35577f
C603 XRX.XCAP.O_PRST_TAIL.t6 VSS 0.35577f
C604 XRX.XCAP.O_PRST_TAIL.n3 VSS 1.4668f
C605 XRX.XCAP.O_PRST_TAIL.n4 VSS 0.80625f
C606 XRX.XCAP.O_PRST_TAIL.t5 VSS 0.35577f
C607 XRX.XCAP.O_PRST_TAIL.t4 VSS 0.35577f
C608 XRX.XCAP.O_PRST_TAIL.n5 VSS 1.4668f
C609 XRX.XCAP.O_PRST_TAIL.n6 VSS 0.42088f
C610 XRX.XCAP.O_PRST_TAIL.t3 VSS 0.35577f
C611 XRX.XCAP.O_PRST_TAIL.t2 VSS 0.35577f
C612 XRX.XCAP.O_PRST_TAIL.n7 VSS 1.4668f
C613 XRX.XCAP.O_PRST_TAIL.n8 VSS 0.42088f
C614 XRX.XCAP.O_PRST_TAIL.t1 VSS 1.86694f
C615 XRX.XCAP.O_PRST_TAIL.n9 VSS 3.44009f
C616 XRX.XCAP.O_PRST_TAIL.n10 VSS 6.46887f
C617 XRX.XCAP.O_QBI.t1 VSS 1.36529f
C618 XRX.XCAP.O_QBI.t9 VSS 0.3572f
C619 XRX.XCAP.O_QBI.t10 VSS 0.3572f
C620 XRX.XCAP.O_QBI.n0 VSS 0.97004f
C621 XRX.XCAP.O_QBI.t8 VSS 1.36855f
C622 XRX.XCAP.O_QBI.n1 VSS 2.18783f
C623 XRX.XCAP.O_QBI.n2 VSS 0.4345f
C624 XRX.XCAP.O_QBI.n3 VSS 3.47797f
C625 XRX.XCAP.O_QBI.n4 VSS 0.48595f
C626 XRX.XCAP.O_QBI.n5 VSS 1.71164f
C627 XRX.XCAP.O_QBI.t5 VSS 1.35633f
C628 XRX.XCAP.O_QBI.t4 VSS 1.34763f
C629 XRX.XCAP.O_QBI.n6 VSS 1.04242f
C630 XRX.XCAP.O_QBI.t11 VSS 1.36624f
C631 XRX.XCAP.O_QBI.t6 VSS 0.3572f
C632 XRX.XCAP.O_QBI.t7 VSS 0.3572f
C633 XRX.XCAP.O_QBI.n7 VSS 0.96289f
C634 XRX.XCAP.O_QBI.n8 VSS 0.48789f
C635 XRX.XCAP.O_QBI.t0 VSS 1.35778f
C636 XRX.XCAP.O_QBI.n9 VSS 0.57498f
C637 XRX.XCAP.O_QBI.t3 VSS 1.35402f
C638 XRX.XCAP.O_QBI.t2 VSS 1.3453f
C639 XRX.XCAP.O_QBI.n10 VSS 0.52306f
C640 XRX.XCAP.O_QBI.n11 VSS 1.05845f
C641 XRX.XCAP.O_QBI.n12 VSS 1.53829f
C642 XRX.XCAP.O_QBI.n13 VSS 1.50493f
C643 XRX.XCAP.O_QBI.n14 VSS 0.8737f
C644 XRX.XCAP.O_QBI.n15 VSS 0.45378f
C645 XRX.XCAP.O_QBI.n16 VSS 2.72459f
C646 XRX.XCAP.O_QBI.n17 VSS 0.66575f
C647 XRX.XCAP.E_QBBUF.t3 VSS 1.15841f
C648 XRX.XCAP.E_QBBUF.t2 VSS 1.15119f
C649 XRX.XCAP.E_QBBUF.n0 VSS 1.11868f
C650 XRX.XCAP.E_QBBUF.t1 VSS 0.55612f
C651 XRX.XCAP.E_QBBUF.t0 VSS 0.54975f
C652 XRX.XCAP.E_QBBUF.n1 VSS 0.49446f
C653 XRX.XCAP.E_QBBUF.n2 VSS 2.10122f
C654 XRX.XCAP.E_QBBUF.n3 VSS 0.12582f
C655 XRX.XCAP.E_QBBUF.n4 VSS 0.13681f
C656 XRX.XCAP.E_QBBUF.n5 VSS 0.13681f
C657 XRX.XCAP.E_QBBUF.n6 VSS 0.12582f
C658 XRX.XCAP.E_QBBUF.n7 VSS 1.1405f
C659 XRX.XCAP.E_QBBUF.n8 VSS 0.12979f
C660 XRX.XCAP.E_QBBUF.n9 VSS 0.13681f
C661 XRX.XCAP.E_QBBUF.n10 VSS 0.1247f
C662 XRX.XCAP.E_QBBUF.n11 VSS 0.29031f
C663 XRX.XCAP.E_QBBUF.n12 VSS 2.47221f
C664 XRX.XCAP.E_QBBUF.n13 VSS 0.71331f
C665 XRX.XCAP.E_QBUF.t0 VSS 1.10555f
C666 XRX.XCAP.E_QBUF.t1 VSS 1.09867f
C667 XRX.XCAP.E_QBUF.n0 VSS 1.06423f
C668 XRX.XCAP.E_QBUF.t2 VSS 0.53094f
C669 XRX.XCAP.E_QBUF.t3 VSS 0.52489f
C670 XRX.XCAP.E_QBUF.n1 VSS 0.47039f
C671 XRX.XCAP.E_QBUF.n2 VSS 1.92533f
C672 XRX.XCAP.E_QBUF.n3 VSS 0.11969f
C673 XRX.XCAP.E_QBUF.n4 VSS 0.13015f
C674 XRX.XCAP.E_QBUF.n5 VSS 0.13015f
C675 XRX.XCAP.E_QBUF.n6 VSS 0.11969f
C676 XRX.XCAP.E_QBUF.n7 VSS 1.08499f
C677 XRX.XCAP.E_QBUF.n8 VSS 0.12347f
C678 XRX.XCAP.E_QBUF.n9 VSS 0.13015f
C679 XRX.XCAP.E_QBUF.n10 VSS 0.11863f
C680 XRX.XCAP.E_QBUF.n11 VSS 0.27618f
C681 XRX.XCAP.E_QBUF.n12 VSS 2.26498f
C682 XRX.XCAP.E_QBUF.n13 VSS 0.65507f
C683 XRX.XCAP.O_QBUF.n0 VSS 0.12253f
C684 XRX.XCAP.O_QBUF.n1 VSS 0.13323f
C685 XRX.XCAP.O_QBUF.n2 VSS 0.13323f
C686 XRX.XCAP.O_QBUF.n3 VSS 0.12253f
C687 XRX.XCAP.O_QBUF.n4 VSS 1.04857f
C688 XRX.XCAP.O_QBUF.n5 VSS 0.12639f
C689 XRX.XCAP.O_QBUF.n6 VSS 0.13323f
C690 XRX.XCAP.O_QBUF.n7 VSS 0.12143f
C691 XRX.XCAP.O_QBUF.n8 VSS 0.28917f
C692 XRX.XCAP.O_QBUF.n9 VSS 2.53404f
C693 XRX.XCAP.O_QBUF.t0 VSS 1.13276f
C694 XRX.XCAP.O_QBUF.t1 VSS 1.12572f
C695 XRX.XCAP.O_QBUF.n10 VSS 1.08943f
C696 XRX.XCAP.O_QBUF.t2 VSS 0.54407f
C697 XRX.XCAP.O_QBUF.t3 VSS 0.53788f
C698 XRX.XCAP.O_QBUF.n11 VSS 0.48153f
C699 XRX.XCAP.O_QBUF.n12 VSS 1.70254f
C700 XRX.XCAP.O_QBUF.n13 VSS 0.78588f
C701 XRX.XCAP.O_QBBUF.n0 VSS 0.13089f
C702 XRX.XCAP.O_QBBUF.n1 VSS 0.14232f
C703 XRX.XCAP.O_QBBUF.n2 VSS 0.14232f
C704 XRX.XCAP.O_QBBUF.n3 VSS 0.13089f
C705 XRX.XCAP.O_QBBUF.n4 VSS 1.1571f
C706 XRX.XCAP.O_QBBUF.n5 VSS 0.13501f
C707 XRX.XCAP.O_QBBUF.n6 VSS 0.14232f
C708 XRX.XCAP.O_QBBUF.n7 VSS 0.12972f
C709 XRX.XCAP.O_QBBUF.n8 VSS 0.30396f
C710 XRX.XCAP.O_QBBUF.n9 VSS 2.67488f
C711 XRX.XCAP.O_QBBUF.t3 VSS 1.19746f
C712 XRX.XCAP.O_QBBUF.t2 VSS 1.18994f
C713 XRX.XCAP.O_QBBUF.n10 VSS 1.16376f
C714 XRX.XCAP.O_QBBUF.t1 VSS 0.57442f
C715 XRX.XCAP.O_QBBUF.t0 VSS 0.5678f
C716 XRX.XCAP.O_QBBUF.n11 VSS 0.51438f
C717 XRX.XCAP.O_QBBUF.n12 VSS 1.90408f
C718 XRX.XCAP.O_QBBUF.n13 VSS 0.85474f
C719 XRX.XCAP.E_QI.n0 VSS 0.63088f
C720 XRX.XCAP.E_QI.n1 VSS 0.45242f
C721 XRX.XCAP.E_QI.n2 VSS 2.36456f
C722 XRX.XCAP.E_QI.t3 VSS 1.34407f
C723 XRX.XCAP.E_QI.t2 VSS 0.33566f
C724 XRX.XCAP.E_QI.t1 VSS 0.33566f
C725 XRX.XCAP.E_QI.n3 VSS 0.96761f
C726 XRX.XCAP.E_QI.n4 VSS 0.47722f
C727 XRX.XCAP.E_QI.t0 VSS 1.33603f
C728 XRX.XCAP.E_QI.n5 VSS 0.57123f
C729 XRX.XCAP.E_QI.t8 VSS 1.35007f
C730 XRX.XCAP.E_QI.t9 VSS 1.34138f
C731 XRX.XCAP.E_QI.n6 VSS 0.51712f
C732 XRX.XCAP.E_QI.n7 VSS 2.04798f
C733 XRX.XCAP.E_QI.t10 VSS 1.34776f
C734 XRX.XCAP.E_QI.t11 VSS 1.33906f
C735 XRX.XCAP.E_QI.n8 VSS 0.52175f
C736 XRX.XCAP.E_QI.n9 VSS 1.16581f
C737 XRX.XCAP.E_QI.t7 VSS 1.34176f
C738 XRX.XCAP.E_QI.t6 VSS 0.33566f
C739 XRX.XCAP.E_QI.t5 VSS 0.33566f
C740 XRX.XCAP.E_QI.n10 VSS 0.96048f
C741 XRX.XCAP.E_QI.n11 VSS 0.48667f
C742 XRX.XCAP.E_QI.t4 VSS 1.33372f
C743 XRX.XCAP.E_QI.n12 VSS 0.8327f
C744 XRX.XCAP.E_QI.n13 VSS 1.61519f
C745 XRX.XCAP.E_QI.n14 VSS 1.78228f
C746 XRX.XCAP.E_QI.n15 VSS 0.81587f
C747 XRX.XCAP.E_QI.n16 VSS 0.40427f
C748 XRX.XCAP.E_QI.n17 VSS 2.92071f
C749 XRX.XCAP.E_QI.n18 VSS 1.02098f
C750 XRX.XCAP.EVEN_DB_BUF.n0 VSS 0.2892f
C751 XRX.XCAP.EVEN_DB_BUF.n1 VSS 0.14295f
C752 XRX.XCAP.EVEN_DB_BUF.n2 VSS 0.15323f
C753 XRX.XCAP.EVEN_DB_BUF.n3 VSS 0.15323f
C754 XRX.XCAP.EVEN_DB_BUF.n4 VSS 0.14482f
C755 XRX.XCAP.EVEN_DB_BUF.n5 VSS 0.28527f
C756 XRX.XCAP.EVEN_DB_BUF.n6 VSS 0.2892f
C757 XRX.XCAP.EVEN_DB_BUF.n7 VSS 0.14295f
C758 XRX.XCAP.EVEN_DB_BUF.n8 VSS 0.15323f
C759 XRX.XCAP.EVEN_DB_BUF.n9 VSS 0.15323f
C760 XRX.XCAP.EVEN_DB_BUF.n10 VSS 0.14482f
C761 XRX.XCAP.EVEN_DB_BUF.n11 VSS 1.62031f
C762 XRX.XCAP.EVEN_DB_BUF.n12 VSS 4.02148f
C763 XRX.XCAP.EVEN_DB_BUF.t3 VSS 1.16864f
C764 XRX.XCAP.EVEN_DB_BUF.t2 VSS 0.22863f
C765 XRX.XCAP.EVEN_DB_BUF.t1 VSS 0.22863f
C766 XRX.XCAP.EVEN_DB_BUF.n13 VSS 0.89894f
C767 XRX.XCAP.EVEN_DB_BUF.n14 VSS 0.45549f
C768 XRX.XCAP.EVEN_DB_BUF.t0 VSS 1.16379f
C769 XRX.XCAP.EVEN_DB_BUF.n15 VSS 0.96977f
C770 XRX.XCAP.EVEN_DB_BUF.t11 VSS 1.1708f
C771 XRX.XCAP.EVEN_DB_BUF.t10 VSS 0.22863f
C772 XRX.XCAP.EVEN_DB_BUF.t9 VSS 0.22863f
C773 XRX.XCAP.EVEN_DB_BUF.n16 VSS 0.90562f
C774 XRX.XCAP.EVEN_DB_BUF.n17 VSS 0.49779f
C775 XRX.XCAP.EVEN_DB_BUF.t8 VSS 0.22863f
C776 XRX.XCAP.EVEN_DB_BUF.t7 VSS 0.22863f
C777 XRX.XCAP.EVEN_DB_BUF.n18 VSS 0.90562f
C778 XRX.XCAP.EVEN_DB_BUF.n19 VSS 0.20872f
C779 XRX.XCAP.EVEN_DB_BUF.t4 VSS 1.1708f
C780 XRX.XCAP.EVEN_DB_BUF.t6 VSS 0.22863f
C781 XRX.XCAP.EVEN_DB_BUF.t5 VSS 0.22863f
C782 XRX.XCAP.EVEN_DB_BUF.n20 VSS 0.90562f
C783 XRX.XCAP.EVEN_DB_BUF.n21 VSS 0.44665f
C784 XRX.XCAP.EVEN_DB_BUF.n22 VSS 0.10228f
C785 XRX.XCAP.EVEN_DB_BUF.n23 VSS 1.79576f
C786 XRX.XCAP.EVEN_DB_BUF.n24 VSS 0.71125f
C787 XRX.XCAP.ODD_DB_BUF.t3 VSS 1.18061f
C788 XRX.XCAP.ODD_DB_BUF.t2 VSS 0.22638f
C789 XRX.XCAP.ODD_DB_BUF.t1 VSS 0.22638f
C790 XRX.XCAP.ODD_DB_BUF.n0 VSS 0.91264f
C791 XRX.XCAP.ODD_DB_BUF.n1 VSS 0.46243f
C792 XRX.XCAP.ODD_DB_BUF.t0 VSS 1.17568f
C793 XRX.XCAP.ODD_DB_BUF.n2 VSS 0.98455f
C794 XRX.XCAP.ODD_DB_BUF.t11 VSS 1.1828f
C795 XRX.XCAP.ODD_DB_BUF.t10 VSS 0.22638f
C796 XRX.XCAP.ODD_DB_BUF.t9 VSS 0.22638f
C797 XRX.XCAP.ODD_DB_BUF.n3 VSS 0.91942f
C798 XRX.XCAP.ODD_DB_BUF.n4 VSS 0.50537f
C799 XRX.XCAP.ODD_DB_BUF.t8 VSS 0.22638f
C800 XRX.XCAP.ODD_DB_BUF.t7 VSS 0.22638f
C801 XRX.XCAP.ODD_DB_BUF.n5 VSS 0.91942f
C802 XRX.XCAP.ODD_DB_BUF.n6 VSS 0.2119f
C803 XRX.XCAP.ODD_DB_BUF.t4 VSS 1.1828f
C804 XRX.XCAP.ODD_DB_BUF.t6 VSS 0.22638f
C805 XRX.XCAP.ODD_DB_BUF.t5 VSS 0.22638f
C806 XRX.XCAP.ODD_DB_BUF.n7 VSS 0.91942f
C807 XRX.XCAP.ODD_DB_BUF.n8 VSS 0.45345f
C808 XRX.XCAP.ODD_DB_BUF.n9 VSS 0.10384f
C809 XRX.XCAP.ODD_DB_BUF.n10 VSS 2.21745f
C810 XRX.XCAP.ODD_DB_BUF.n11 VSS 0.29361f
C811 XRX.XCAP.ODD_DB_BUF.n12 VSS 0.14513f
C812 XRX.XCAP.ODD_DB_BUF.n13 VSS 0.15556f
C813 XRX.XCAP.ODD_DB_BUF.n14 VSS 0.15556f
C814 XRX.XCAP.ODD_DB_BUF.n15 VSS 0.14702f
C815 XRX.XCAP.ODD_DB_BUF.n16 VSS 0.26874f
C816 XRX.XCAP.ODD_DB_BUF.n17 VSS 0.29361f
C817 XRX.XCAP.ODD_DB_BUF.n18 VSS 0.14513f
C818 XRX.XCAP.ODD_DB_BUF.n19 VSS 0.15556f
C819 XRX.XCAP.ODD_DB_BUF.n20 VSS 0.15556f
C820 XRX.XCAP.ODD_DB_BUF.n21 VSS 0.14702f
C821 XRX.XCAP.ODD_DB_BUF.n22 VSS 1.73534f
C822 XRX.XCAP.ODD_DB_BUF.n23 VSS 3.87678f
C823 XRX.XCAP.ODD_DB_BUF.n24 VSS 0.93564f
C824 XRX.XCAP.O_QI.n0 VSS 0.81035f
C825 XRX.XCAP.O_QI.n1 VSS 0.40154f
C826 XRX.XCAP.O_QI.n2 VSS 3.28197f
C827 XRX.XCAP.O_QI.t7 VSS 1.33831f
C828 XRX.XCAP.O_QI.t8 VSS 0.33666f
C829 XRX.XCAP.O_QI.t9 VSS 0.33666f
C830 XRX.XCAP.O_QI.n3 VSS 0.96107f
C831 XRX.XCAP.O_QI.n4 VSS 0.474f
C832 XRX.XCAP.O_QI.t6 VSS 1.33027f
C833 XRX.XCAP.O_QI.n5 VSS 0.56737f
C834 XRX.XCAP.O_QI.t10 VSS 1.34677f
C835 XRX.XCAP.O_QI.t11 VSS 1.33815f
C836 XRX.XCAP.O_QI.n6 VSS 0.51362f
C837 XRX.XCAP.O_QI.n7 VSS 2.03413f
C838 XRX.XCAP.O_QI.t1 VSS 1.34448f
C839 XRX.XCAP.O_QI.t2 VSS 1.33584f
C840 XRX.XCAP.O_QI.n8 VSS 0.51822f
C841 XRX.XCAP.O_QI.n9 VSS 1.04296f
C842 XRX.XCAP.O_QI.t0 VSS 1.33602f
C843 XRX.XCAP.O_QI.t3 VSS 0.33666f
C844 XRX.XCAP.O_QI.t4 VSS 0.33666f
C845 XRX.XCAP.O_QI.n10 VSS 0.95398f
C846 XRX.XCAP.O_QI.n11 VSS 0.48338f
C847 XRX.XCAP.O_QI.t5 VSS 1.32798f
C848 XRX.XCAP.O_QI.n12 VSS 0.91671f
C849 XRX.XCAP.O_QI.n13 VSS 1.6296f
C850 XRX.XCAP.O_QI.n14 VSS 2.1671f
C851 XRX.XCAP.O_QI.n15 VSS 0.58411f
C852 XRX.XCAP.O_QI.n16 VSS 0.46929f
C853 XRX.XCAP.O_QI.n17 VSS 2.17206f
C854 XRX.XCAP.O_QI.n18 VSS 0.4681f
C855 XRX.XCAP.E_PSET_TAIL.t11 VSS 1.97714f
C856 XRX.XCAP.E_PSET_TAIL.t10 VSS 0.36826f
C857 XRX.XCAP.E_PSET_TAIL.t9 VSS 0.36826f
C858 XRX.XCAP.E_PSET_TAIL.n0 VSS 1.54688f
C859 XRX.XCAP.E_PSET_TAIL.n1 VSS 0.85027f
C860 XRX.XCAP.E_PSET_TAIL.t8 VSS 0.36826f
C861 XRX.XCAP.E_PSET_TAIL.t7 VSS 0.36826f
C862 XRX.XCAP.E_PSET_TAIL.n2 VSS 1.54688f
C863 XRX.XCAP.E_PSET_TAIL.n3 VSS 0.44386f
C864 XRX.XCAP.E_PSET_TAIL.t6 VSS 0.36826f
C865 XRX.XCAP.E_PSET_TAIL.t5 VSS 0.36826f
C866 XRX.XCAP.E_PSET_TAIL.n4 VSS 1.54688f
C867 XRX.XCAP.E_PSET_TAIL.n5 VSS 0.44386f
C868 XRX.XCAP.E_PSET_TAIL.t4 VSS 1.96193f
C869 XRX.XCAP.E_PSET_TAIL.n6 VSS 2.2193f
C870 XRX.XCAP.E_PSET_TAIL.t0 VSS 0.45042f
C871 XRX.XCAP.E_PSET_TAIL.t1 VSS 0.44756f
C872 XRX.XCAP.E_PSET_TAIL.n7 VSS 1.55899f
C873 XRX.XCAP.E_PSET_TAIL.t2 VSS 0.44756f
C874 XRX.XCAP.E_PSET_TAIL.t3 VSS 0.44756f
C875 XRX.XCAP.E_PSET_TAIL.n8 VSS 1.54688f
C876 XRX.XCAP.E_PSET_TAIL.n9 VSS 2.2126f
C877 XRX.XCAP.E_PSET_TAIL.n10 VSS 3.81367f
C878 XRX.XCAP.O_PSET_TAIL.t3 VSS 0.43217f
C879 XRX.XCAP.O_PSET_TAIL.t0 VSS 0.43217f
C880 XRX.XCAP.O_PSET_TAIL.n0 VSS 1.46688f
C881 XRX.XCAP.O_PSET_TAIL.t1 VSS 0.43507f
C882 XRX.XCAP.O_PSET_TAIL.t2 VSS 0.43217f
C883 XRX.XCAP.O_PSET_TAIL.n1 VSS 1.45549f
C884 XRX.XCAP.O_PSET_TAIL.n2 VSS 2.74646f
C885 XRX.XCAP.O_PSET_TAIL.t11 VSS 1.86754f
C886 XRX.XCAP.O_PSET_TAIL.t10 VSS 0.35358f
C887 XRX.XCAP.O_PSET_TAIL.t9 VSS 0.35358f
C888 XRX.XCAP.O_PSET_TAIL.n3 VSS 1.45549f
C889 XRX.XCAP.O_PSET_TAIL.n4 VSS 0.80004f
C890 XRX.XCAP.O_PSET_TAIL.t8 VSS 0.35358f
C891 XRX.XCAP.O_PSET_TAIL.t7 VSS 0.35358f
C892 XRX.XCAP.O_PSET_TAIL.n5 VSS 1.45549f
C893 XRX.XCAP.O_PSET_TAIL.n6 VSS 0.41764f
C894 XRX.XCAP.O_PSET_TAIL.t6 VSS 0.35358f
C895 XRX.XCAP.O_PSET_TAIL.t5 VSS 0.35358f
C896 XRX.XCAP.O_PSET_TAIL.n7 VSS 1.45549f
C897 XRX.XCAP.O_PSET_TAIL.n8 VSS 0.41764f
C898 XRX.XCAP.O_PSET_TAIL.t4 VSS 1.8531f
C899 XRX.XCAP.O_PSET_TAIL.n9 VSS 1.58693f
C900 XRX.XCAP.O_PSET_TAIL.n10 VSS 4.05229f
C901 XRX.XCAP.E_SET_TAIL.t11 VSS 0.3085f
C902 XRX.XCAP.E_SET_TAIL.t9 VSS 0.3085f
C903 XRX.XCAP.E_SET_TAIL.n0 VSS 0.69793f
C904 XRX.XCAP.E_SET_TAIL.t8 VSS 0.31184f
C905 XRX.XCAP.E_SET_TAIL.t10 VSS 0.3085f
C906 XRX.XCAP.E_SET_TAIL.n1 VSS 0.69236f
C907 XRX.XCAP.E_SET_TAIL.n2 VSS 0.55269f
C908 XRX.XCAP.E_SET_TAIL.t7 VSS 0.89675f
C909 XRX.XCAP.E_SET_TAIL.t6 VSS 0.17282f
C910 XRX.XCAP.E_SET_TAIL.t5 VSS 0.17282f
C911 XRX.XCAP.E_SET_TAIL.n3 VSS 0.69236f
C912 XRX.XCAP.E_SET_TAIL.n4 VSS 0.3902f
C913 XRX.XCAP.E_SET_TAIL.t4 VSS 0.17282f
C914 XRX.XCAP.E_SET_TAIL.t3 VSS 0.17282f
C915 XRX.XCAP.E_SET_TAIL.n5 VSS 0.69236f
C916 XRX.XCAP.E_SET_TAIL.n6 VSS 0.20528f
C917 XRX.XCAP.E_SET_TAIL.t0 VSS 0.89675f
C918 XRX.XCAP.E_SET_TAIL.t2 VSS 0.17282f
C919 XRX.XCAP.E_SET_TAIL.t1 VSS 0.17282f
C920 XRX.XCAP.E_SET_TAIL.n7 VSS 0.69236f
C921 XRX.XCAP.E_SET_TAIL.n8 VSS 0.59761f
C922 XRX.XCAP.E_SET_TAIL.n9 VSS 1.04754f
C923 XRX.XCAP.O_SET_TAIL.t10 VSS 0.87387f
C924 XRX.XCAP.O_SET_TAIL.t9 VSS 0.17073f
C925 XRX.XCAP.O_SET_TAIL.t8 VSS 0.17073f
C926 XRX.XCAP.O_SET_TAIL.n0 VSS 0.67242f
C927 XRX.XCAP.O_SET_TAIL.n1 VSS 0.37897f
C928 XRX.XCAP.O_SET_TAIL.t7 VSS 0.17073f
C929 XRX.XCAP.O_SET_TAIL.t6 VSS 0.17073f
C930 XRX.XCAP.O_SET_TAIL.n2 VSS 0.67242f
C931 XRX.XCAP.O_SET_TAIL.n3 VSS 0.19937f
C932 XRX.XCAP.O_SET_TAIL.t3 VSS 0.87387f
C933 XRX.XCAP.O_SET_TAIL.t5 VSS 0.17073f
C934 XRX.XCAP.O_SET_TAIL.t4 VSS 0.17073f
C935 XRX.XCAP.O_SET_TAIL.n4 VSS 0.67242f
C936 XRX.XCAP.O_SET_TAIL.n5 VSS 0.55941f
C937 XRX.XCAP.O_SET_TAIL.t2 VSS 0.30067f
C938 XRX.XCAP.O_SET_TAIL.t0 VSS 0.30067f
C939 XRX.XCAP.O_SET_TAIL.n6 VSS 0.67784f
C940 XRX.XCAP.O_SET_TAIL.t11 VSS 0.30393f
C941 XRX.XCAP.O_SET_TAIL.t1 VSS 0.30067f
C942 XRX.XCAP.O_SET_TAIL.n7 VSS 0.67242f
C943 XRX.XCAP.O_SET_TAIL.n8 VSS 0.49654f
C944 XRX.XCAP.O_SET_TAIL.n9 VSS 0.70815f
C945 XRX.XCAP.E_RST_TAIL.t8 VSS 0.69833f
C946 XRX.XCAP.E_RST_TAIL.t7 VSS 0.14177f
C947 XRX.XCAP.E_RST_TAIL.t6 VSS 0.14177f
C948 XRX.XCAP.E_RST_TAIL.n0 VSS 0.53282f
C949 XRX.XCAP.E_RST_TAIL.n1 VSS 0.30029f
C950 XRX.XCAP.E_RST_TAIL.t5 VSS 0.14177f
C951 XRX.XCAP.E_RST_TAIL.t4 VSS 0.14177f
C952 XRX.XCAP.E_RST_TAIL.n2 VSS 0.53282f
C953 XRX.XCAP.E_RST_TAIL.n3 VSS 0.15798f
C954 XRX.XCAP.E_RST_TAIL.t3 VSS 0.14177f
C955 XRX.XCAP.E_RST_TAIL.t2 VSS 0.14177f
C956 XRX.XCAP.E_RST_TAIL.n4 VSS 0.53282f
C957 XRX.XCAP.E_RST_TAIL.n5 VSS 0.12767f
C958 XRX.XCAP.E_RST_TAIL.t1 VSS 0.69618f
C959 XRX.XCAP.E_RST_TAIL.n6 VSS 0.39529f
C960 XRX.XCAP.E_RST_TAIL.t10 VSS 0.25242f
C961 XRX.XCAP.E_RST_TAIL.t11 VSS 0.25242f
C962 XRX.XCAP.E_RST_TAIL.n7 VSS 0.53711f
C963 XRX.XCAP.E_RST_TAIL.t0 VSS 0.25528f
C964 XRX.XCAP.E_RST_TAIL.t9 VSS 0.25242f
C965 XRX.XCAP.E_RST_TAIL.n8 VSS 0.53282f
C966 XRX.XCAP.E_RST_TAIL.n9 VSS 0.74854f
C967 XRX.XCAP.E_RST_TAIL.n10 VSS 0.8009f
C968 XRX.XCAP.O_RST_TAIL.t2 VSS 0.26572f
C969 XRX.XCAP.O_RST_TAIL.t3 VSS 0.26572f
C970 XRX.XCAP.O_RST_TAIL.n0 VSS 0.59423f
C971 XRX.XCAP.O_RST_TAIL.t0 VSS 0.26861f
C972 XRX.XCAP.O_RST_TAIL.t1 VSS 0.26572f
C973 XRX.XCAP.O_RST_TAIL.n1 VSS 0.58949f
C974 XRX.XCAP.O_RST_TAIL.n2 VSS 1.09562f
C975 XRX.XCAP.O_RST_TAIL.t11 VSS 0.77034f
C976 XRX.XCAP.O_RST_TAIL.t10 VSS 0.15459f
C977 XRX.XCAP.O_RST_TAIL.t9 VSS 0.15459f
C978 XRX.XCAP.O_RST_TAIL.n3 VSS 0.58949f
C979 XRX.XCAP.O_RST_TAIL.n4 VSS 0.33223f
C980 XRX.XCAP.O_RST_TAIL.t8 VSS 0.15459f
C981 XRX.XCAP.O_RST_TAIL.t7 VSS 0.15459f
C982 XRX.XCAP.O_RST_TAIL.n5 VSS 0.58949f
C983 XRX.XCAP.O_RST_TAIL.n6 VSS 0.17478f
C984 XRX.XCAP.O_RST_TAIL.t6 VSS 0.15459f
C985 XRX.XCAP.O_RST_TAIL.t5 VSS 0.15459f
C986 XRX.XCAP.O_RST_TAIL.n7 VSS 0.58949f
C987 XRX.XCAP.O_RST_TAIL.n8 VSS 0.14125f
C988 XRX.XCAP.O_RST_TAIL.t4 VSS 0.76792f
C989 XRX.XCAP.O_RST_TAIL.n9 VSS 0.46717f
C990 XRX.XCAP.O_RST_TAIL.n10 VSS 1.44128f
C991 XRX.XFRONT.XFE_E.XP.t31 VSS 1.38807f
C992 XRX.XFRONT.XFE_E.XP.t22 VSS 1.39936f
C993 XRX.XFRONT.XFE_E.XP.t24 VSS 0.29892f
C994 XRX.XFRONT.XFE_E.XP.t23 VSS 0.29892f
C995 XRX.XFRONT.XFE_E.XP.n0 VSS 1.05643f
C996 XRX.XFRONT.XFE_E.XP.n1 VSS 0.58069f
C997 XRX.XFRONT.XFE_E.XP.t26 VSS 0.29892f
C998 XRX.XFRONT.XFE_E.XP.t25 VSS 0.29892f
C999 XRX.XFRONT.XFE_E.XP.n2 VSS 1.05643f
C1000 XRX.XFRONT.XFE_E.XP.n3 VSS 0.30313f
C1001 XRX.XFRONT.XFE_E.XP.t28 VSS 0.29892f
C1002 XRX.XFRONT.XFE_E.XP.t27 VSS 0.29892f
C1003 XRX.XFRONT.XFE_E.XP.n4 VSS 1.05643f
C1004 XRX.XFRONT.XFE_E.XP.n5 VSS 0.30313f
C1005 XRX.XFRONT.XFE_E.XP.t30 VSS 0.29892f
C1006 XRX.XFRONT.XFE_E.XP.t29 VSS 0.29892f
C1007 XRX.XFRONT.XFE_E.XP.n6 VSS 1.05643f
C1008 XRX.XFRONT.XFE_E.XP.n7 VSS 0.28822f
C1009 XRX.XFRONT.XFE_E.XP.n8 VSS 1.55768f
C1010 XRX.XFRONT.XFE_E.XP.n9 VSS 0.33737f
C1011 XRX.XFRONT.XFE_E.XP.n10 VSS 0.16675f
C1012 XRX.XFRONT.XFE_E.XP.n11 VSS 0.17874f
C1013 XRX.XFRONT.XFE_E.XP.n12 VSS 0.17874f
C1014 XRX.XFRONT.XFE_E.XP.n13 VSS 0.16893f
C1015 XRX.XFRONT.XFE_E.XP.n14 VSS 1.42089f
C1016 XRX.XFRONT.XFE_E.XP.n15 VSS 0.24239f
C1017 XRX.XFRONT.XFE_E.XP.n16 VSS 0.25025f
C1018 XRX.XFRONT.XFE_E.XP.n17 VSS 0.25025f
C1019 XRX.XFRONT.XFE_E.XP.n18 VSS 0.17874f
C1020 XRX.XFRONT.XFE_E.XP.n19 VSS 0.11591f
C1021 XRX.XFRONT.XFE_E.XP.n20 VSS 0.11591f
C1022 XRX.XFRONT.XFE_E.XP.n21 VSS 0.33737f
C1023 XRX.XFRONT.XFE_E.XP.n22 VSS 0.25051f
C1024 XRX.XFRONT.XFE_E.XP.n23 VSS 0.25051f
C1025 XRX.XFRONT.XFE_E.XP.n24 VSS 0.25051f
C1026 XRX.XFRONT.XFE_E.XP.n25 VSS 0.25051f
C1027 XRX.XFRONT.XFE_E.XP.n26 VSS 0.25051f
C1028 XRX.XFRONT.XFE_E.XP.n27 VSS 0.4949f
C1029 XRX.XFRONT.XFE_E.XP.n28 VSS 0.16675f
C1030 XRX.XFRONT.XFE_E.XP.n29 VSS 0.17874f
C1031 XRX.XFRONT.XFE_E.XP.n30 VSS 0.17874f
C1032 XRX.XFRONT.XFE_E.XP.n31 VSS 0.17874f
C1033 XRX.XFRONT.XFE_E.XP.n32 VSS 0.17874f
C1034 XRX.XFRONT.XFE_E.XP.n33 VSS 0.17874f
C1035 XRX.XFRONT.XFE_E.XP.n34 VSS 0.11591f
C1036 XRX.XFRONT.XFE_E.XP.n35 VSS 0.11591f
C1037 XRX.XFRONT.XFE_E.XP.n36 VSS 0.11565f
C1038 XRX.XFRONT.XFE_E.XP.n37 VSS 0.17874f
C1039 XRX.XFRONT.XFE_E.XP.n38 VSS 0.17874f
C1040 XRX.XFRONT.XFE_E.XP.n39 VSS 0.4949f
C1041 XRX.XFRONT.XFE_E.XP.n40 VSS 0.16675f
C1042 XRX.XFRONT.XFE_E.XP.n41 VSS 0.3371f
C1043 XRX.XFRONT.XFE_E.XP.n42 VSS 0.17874f
C1044 XRX.XFRONT.XFE_E.XP.n43 VSS 0.17874f
C1045 XRX.XFRONT.XFE_E.XP.n44 VSS 0.29566f
C1046 XRX.XFRONT.XFE_E.XP.n45 VSS 1.795f
C1047 XRX.XFRONT.XFE_E.XP.n46 VSS 3.10172f
C1048 XRX.XFRONT.XFE_E.XP.n47 VSS 1.47542f
C1049 XRX.XFRONT.XFE_E.XP.n48 VSS 3.45737f
C1050 XRX.XFRONT.XFE_E.XP.t21 VSS 1.39936f
C1051 XRX.XFRONT.XFE_E.XP.t20 VSS 0.29892f
C1052 XRX.XFRONT.XFE_E.XP.t19 VSS 0.29892f
C1053 XRX.XFRONT.XFE_E.XP.n49 VSS 1.05643f
C1054 XRX.XFRONT.XFE_E.XP.n50 VSS 0.52103f
C1055 XRX.XFRONT.XFE_E.XP.t14 VSS 1.39935f
C1056 XRX.XFRONT.XFE_E.XP.t16 VSS 0.29892f
C1057 XRX.XFRONT.XFE_E.XP.t15 VSS 0.29892f
C1058 XRX.XFRONT.XFE_E.XP.n51 VSS 1.05643f
C1059 XRX.XFRONT.XFE_E.XP.n52 VSS 0.58069f
C1060 XRX.XFRONT.XFE_E.XP.t18 VSS 0.29892f
C1061 XRX.XFRONT.XFE_E.XP.t17 VSS 0.29892f
C1062 XRX.XFRONT.XFE_E.XP.n53 VSS 1.05643f
C1063 XRX.XFRONT.XFE_E.XP.n54 VSS 0.24348f
C1064 XRX.XFRONT.XFE_E.XP.n55 VSS 1.37228f
C1065 XRX.XFRONT.XFE_E.XP.n56 VSS 2.05638f
C1066 XRX.XFRONT.XFE_E.XP.t1 VSS 1.47571f
C1067 XRX.XFRONT.XFE_E.XP.t0 VSS 1.47329f
C1068 XRX.XFRONT.XFE_E.XP.n57 VSS 2.36091f
C1069 XRX.XFRONT.XFE_E.XP.n58 VSS 2.92298f
C1070 XRX.XFRONT.XFE_E.XP.t13 VSS 1.43044f
C1071 XRX.XFRONT.XFE_E.XP.t12 VSS 0.33163f
C1072 XRX.XFRONT.XFE_E.XP.t11 VSS 0.33163f
C1073 XRX.XFRONT.XFE_E.XP.n59 VSS 1.04864f
C1074 XRX.XFRONT.XFE_E.XP.n60 VSS 0.591f
C1075 XRX.XFRONT.XFE_E.XP.t10 VSS 0.33163f
C1076 XRX.XFRONT.XFE_E.XP.t9 VSS 0.33163f
C1077 XRX.XFRONT.XFE_E.XP.n61 VSS 1.04864f
C1078 XRX.XFRONT.XFE_E.XP.n62 VSS 0.25126f
C1079 XRX.XFRONT.XFE_E.XP.t2 VSS 1.43044f
C1080 XRX.XFRONT.XFE_E.XP.t4 VSS 0.33163f
C1081 XRX.XFRONT.XFE_E.XP.t3 VSS 0.33163f
C1082 XRX.XFRONT.XFE_E.XP.n63 VSS 1.04864f
C1083 XRX.XFRONT.XFE_E.XP.n64 VSS 0.591f
C1084 XRX.XFRONT.XFE_E.XP.t6 VSS 0.33163f
C1085 XRX.XFRONT.XFE_E.XP.t5 VSS 0.33163f
C1086 XRX.XFRONT.XFE_E.XP.n65 VSS 1.04864f
C1087 XRX.XFRONT.XFE_E.XP.n66 VSS 0.31092f
C1088 XRX.XFRONT.XFE_E.XP.t8 VSS 0.33163f
C1089 XRX.XFRONT.XFE_E.XP.t7 VSS 0.33163f
C1090 XRX.XFRONT.XFE_E.XP.n67 VSS 1.04864f
C1091 XRX.XFRONT.XFE_E.XP.n68 VSS 0.25126f
C1092 XRX.XFRONT.XFE_E.XP.n69 VSS 0.78552f
C1093 XRX.XFRONT.XFE_E.XP.n70 VSS 1.62307f
C1094 XRX.XFRONT.XFE_E.XP.n71 VSS 0.95385f
C1095 XRX.XFRONT.XFE_E.XP.n72 VSS 1.25315f
C1096 XRX.XFRONT.XFE_E.XP.n73 VSS 0.32704f
C1097 XRX.XFRONT.XFE_E.XP.n74 VSS 0.16675f
C1098 XRX.XFRONT.XFE_E.XP.n75 VSS 0.17874f
C1099 XRX.XFRONT.XFE_E.XP.n76 VSS 0.17874f
C1100 XRX.XFRONT.XFE_E.XP.n77 VSS 0.16904f
C1101 XRX.XFRONT.XFE_E.XP.n78 VSS 0.42062f
C1102 XRX.XFRONT.XFE_E.XP.n79 VSS 0.8627f
C1103 XRX.XFRONT.XFE_E.XN.n0 VSS 0.32954f
C1104 XRX.XFRONT.XFE_E.XN.n1 VSS 0.16803f
C1105 XRX.XFRONT.XFE_E.XN.n2 VSS 0.18011f
C1106 XRX.XFRONT.XFE_E.XN.n3 VSS 0.18011f
C1107 XRX.XFRONT.XFE_E.XN.n4 VSS 0.17033f
C1108 XRX.XFRONT.XFE_E.XN.n5 VSS 1.24336f
C1109 XRX.XFRONT.XFE_E.XN.t24 VSS 1.40929f
C1110 XRX.XFRONT.XFE_E.XN.t23 VSS 0.30047f
C1111 XRX.XFRONT.XFE_E.XN.t22 VSS 0.30047f
C1112 XRX.XFRONT.XFE_E.XN.n6 VSS 1.06449f
C1113 XRX.XFRONT.XFE_E.XN.n7 VSS 0.58512f
C1114 XRX.XFRONT.XFE_E.XN.t21 VSS 0.30047f
C1115 XRX.XFRONT.XFE_E.XN.t20 VSS 0.30047f
C1116 XRX.XFRONT.XFE_E.XN.n8 VSS 1.06449f
C1117 XRX.XFRONT.XFE_E.XN.n9 VSS 0.30545f
C1118 XRX.XFRONT.XFE_E.XN.t19 VSS 0.30047f
C1119 XRX.XFRONT.XFE_E.XN.t18 VSS 0.30047f
C1120 XRX.XFRONT.XFE_E.XN.n10 VSS 1.06449f
C1121 XRX.XFRONT.XFE_E.XN.n11 VSS 0.30545f
C1122 XRX.XFRONT.XFE_E.XN.t17 VSS 0.30047f
C1123 XRX.XFRONT.XFE_E.XN.t16 VSS 0.30047f
C1124 XRX.XFRONT.XFE_E.XN.n12 VSS 1.06449f
C1125 XRX.XFRONT.XFE_E.XN.n13 VSS 0.24533f
C1126 XRX.XFRONT.XFE_E.XN.t15 VSS 1.40101f
C1127 XRX.XFRONT.XFE_E.XN.n14 VSS 1.66511f
C1128 XRX.XFRONT.XFE_E.XN.n15 VSS 0.17033f
C1129 XRX.XFRONT.XFE_E.XN.n16 VSS 0.16803f
C1130 XRX.XFRONT.XFE_E.XN.n17 VSS 0.18011f
C1131 XRX.XFRONT.XFE_E.XN.n18 VSS 0.18011f
C1132 XRX.XFRONT.XFE_E.XN.n19 VSS 0.32954f
C1133 XRX.XFRONT.XFE_E.XN.n20 VSS 0.3775f
C1134 XRX.XFRONT.XFE_E.XN.n21 VSS 2.16471f
C1135 XRX.XFRONT.XFE_E.XN.n22 VSS 0.9973f
C1136 XRX.XFRONT.XFE_E.XN.n23 VSS 1.42665f
C1137 XRX.XFRONT.XFE_E.XN.t30 VSS 1.43937f
C1138 XRX.XFRONT.XFE_E.XN.t31 VSS 0.33222f
C1139 XRX.XFRONT.XFE_E.XN.t5 VSS 0.33222f
C1140 XRX.XFRONT.XFE_E.XN.n24 VSS 1.05664f
C1141 XRX.XFRONT.XFE_E.XN.n25 VSS 0.59551f
C1142 XRX.XFRONT.XFE_E.XN.t6 VSS 0.33222f
C1143 XRX.XFRONT.XFE_E.XN.t7 VSS 0.33222f
C1144 XRX.XFRONT.XFE_E.XN.n26 VSS 1.05664f
C1145 XRX.XFRONT.XFE_E.XN.n27 VSS 0.25318f
C1146 XRX.XFRONT.XFE_E.XN.t8 VSS 1.43937f
C1147 XRX.XFRONT.XFE_E.XN.t10 VSS 0.33222f
C1148 XRX.XFRONT.XFE_E.XN.t11 VSS 0.33222f
C1149 XRX.XFRONT.XFE_E.XN.n28 VSS 1.05664f
C1150 XRX.XFRONT.XFE_E.XN.n29 VSS 0.59551f
C1151 XRX.XFRONT.XFE_E.XN.t4 VSS 0.33222f
C1152 XRX.XFRONT.XFE_E.XN.t9 VSS 0.33222f
C1153 XRX.XFRONT.XFE_E.XN.n30 VSS 1.05664f
C1154 XRX.XFRONT.XFE_E.XN.n31 VSS 0.31329f
C1155 XRX.XFRONT.XFE_E.XN.t2 VSS 0.33222f
C1156 XRX.XFRONT.XFE_E.XN.t3 VSS 0.33222f
C1157 XRX.XFRONT.XFE_E.XN.n32 VSS 1.05664f
C1158 XRX.XFRONT.XFE_E.XN.n33 VSS 0.25318f
C1159 XRX.XFRONT.XFE_E.XN.n34 VSS 0.85518f
C1160 XRX.XFRONT.XFE_E.XN.n35 VSS 1.72642f
C1161 XRX.XFRONT.XFE_E.XN.t0 VSS 1.47912f
C1162 XRX.XFRONT.XFE_E.XN.t1 VSS 1.48871f
C1163 XRX.XFRONT.XFE_E.XN.n36 VSS 2.31351f
C1164 XRX.XFRONT.XFE_E.XN.n37 VSS 2.80884f
C1165 XRX.XFRONT.XFE_E.XN.t27 VSS 0.30305f
C1166 XRX.XFRONT.XFE_E.XN.t26 VSS 0.30047f
C1167 XRX.XFRONT.XFE_E.XN.n38 VSS 1.07282f
C1168 XRX.XFRONT.XFE_E.XN.t25 VSS 0.30047f
C1169 XRX.XFRONT.XFE_E.XN.t29 VSS 0.30047f
C1170 XRX.XFRONT.XFE_E.XN.n39 VSS 1.06449f
C1171 XRX.XFRONT.XFE_E.XN.n40 VSS 0.53944f
C1172 XRX.XFRONT.XFE_E.XN.t12 VSS 0.30047f
C1173 XRX.XFRONT.XFE_E.XN.t13 VSS 0.30047f
C1174 XRX.XFRONT.XFE_E.XN.n41 VSS 1.06449f
C1175 XRX.XFRONT.XFE_E.XN.t28 VSS 0.30047f
C1176 XRX.XFRONT.XFE_E.XN.t14 VSS 0.30304f
C1177 XRX.XFRONT.XFE_E.XN.n42 VSS 1.07282f
C1178 XRX.XFRONT.XFE_E.XN.n43 VSS 1.44722f
C1179 XRX.XFRONT.XFE_E.XN.n44 VSS 1.69004f
C1180 XRX.XFRONT.XFE_E.XN.n45 VSS 1.44329f
C1181 XRX.XFRONT.XFE_E.XN.n46 VSS 3.21788f
C1182 XRX.XFRONT.XFE_E.XN.n47 VSS 0.24424f
C1183 XRX.XFRONT.XFE_E.XN.n48 VSS 0.25216f
C1184 XRX.XFRONT.XFE_E.XN.n49 VSS 0.25216f
C1185 XRX.XFRONT.XFE_E.XN.n50 VSS 0.18011f
C1186 XRX.XFRONT.XFE_E.XN.n51 VSS 0.11679f
C1187 XRX.XFRONT.XFE_E.XN.n52 VSS 0.11679f
C1188 XRX.XFRONT.XFE_E.XN.n53 VSS 0.33994f
C1189 XRX.XFRONT.XFE_E.XN.n54 VSS 0.25242f
C1190 XRX.XFRONT.XFE_E.XN.n55 VSS 0.25242f
C1191 XRX.XFRONT.XFE_E.XN.n56 VSS 0.25242f
C1192 XRX.XFRONT.XFE_E.XN.n57 VSS 0.25242f
C1193 XRX.XFRONT.XFE_E.XN.n58 VSS 0.25242f
C1194 XRX.XFRONT.XFE_E.XN.n59 VSS 0.49868f
C1195 XRX.XFRONT.XFE_E.XN.n60 VSS 0.16803f
C1196 XRX.XFRONT.XFE_E.XN.n61 VSS 0.18011f
C1197 XRX.XFRONT.XFE_E.XN.n62 VSS 0.18011f
C1198 XRX.XFRONT.XFE_E.XN.n63 VSS 0.18011f
C1199 XRX.XFRONT.XFE_E.XN.n64 VSS 0.18011f
C1200 XRX.XFRONT.XFE_E.XN.n65 VSS 0.18011f
C1201 XRX.XFRONT.XFE_E.XN.n66 VSS 0.11679f
C1202 XRX.XFRONT.XFE_E.XN.n67 VSS 0.11679f
C1203 XRX.XFRONT.XFE_E.XN.n68 VSS 0.11653f
C1204 XRX.XFRONT.XFE_E.XN.n69 VSS 0.18011f
C1205 XRX.XFRONT.XFE_E.XN.n70 VSS 0.18011f
C1206 XRX.XFRONT.XFE_E.XN.n71 VSS 0.49868f
C1207 XRX.XFRONT.XFE_E.XN.n72 VSS 0.16803f
C1208 XRX.XFRONT.XFE_E.XN.n73 VSS 0.33968f
C1209 XRX.XFRONT.XFE_E.XN.n74 VSS 0.18011f
C1210 XRX.XFRONT.XFE_E.XN.n75 VSS 0.18011f
C1211 XRX.XFRONT.XFE_E.XN.n76 VSS 0.29791f
C1212 XRX.XFRONT.XFE_E.XN.n77 VSS 1.89723f
C1213 XRX.XFRONT.XFE_E.XN.n78 VSS 1.10618f
C1214 XRX.XFRONT.XFE_O.XN.t31 VSS 1.40101f
C1215 XRX.XFRONT.XFE_O.XN.t22 VSS 1.40929f
C1216 XRX.XFRONT.XFE_O.XN.t24 VSS 0.30047f
C1217 XRX.XFRONT.XFE_O.XN.t23 VSS 0.30047f
C1218 XRX.XFRONT.XFE_O.XN.n0 VSS 1.06449f
C1219 XRX.XFRONT.XFE_O.XN.n1 VSS 0.58512f
C1220 XRX.XFRONT.XFE_O.XN.t26 VSS 0.30047f
C1221 XRX.XFRONT.XFE_O.XN.t25 VSS 0.30047f
C1222 XRX.XFRONT.XFE_O.XN.n2 VSS 1.06449f
C1223 XRX.XFRONT.XFE_O.XN.n3 VSS 0.30545f
C1224 XRX.XFRONT.XFE_O.XN.t28 VSS 0.30047f
C1225 XRX.XFRONT.XFE_O.XN.t27 VSS 0.30047f
C1226 XRX.XFRONT.XFE_O.XN.n4 VSS 1.06449f
C1227 XRX.XFRONT.XFE_O.XN.n5 VSS 0.30545f
C1228 XRX.XFRONT.XFE_O.XN.t30 VSS 0.30047f
C1229 XRX.XFRONT.XFE_O.XN.t29 VSS 0.30047f
C1230 XRX.XFRONT.XFE_O.XN.n6 VSS 1.06449f
C1231 XRX.XFRONT.XFE_O.XN.n7 VSS 0.24533f
C1232 XRX.XFRONT.XFE_O.XN.n8 VSS 1.66511f
C1233 XRX.XFRONT.XFE_O.XN.n9 VSS 0.32954f
C1234 XRX.XFRONT.XFE_O.XN.n10 VSS 0.16803f
C1235 XRX.XFRONT.XFE_O.XN.n11 VSS 0.18011f
C1236 XRX.XFRONT.XFE_O.XN.n12 VSS 0.18011f
C1237 XRX.XFRONT.XFE_O.XN.n13 VSS 0.17033f
C1238 XRX.XFRONT.XFE_O.XN.n14 VSS 0.3775f
C1239 XRX.XFRONT.XFE_O.XN.n15 VSS 2.16471f
C1240 XRX.XFRONT.XFE_O.XN.n16 VSS 0.9973f
C1241 XRX.XFRONT.XFE_O.XN.n17 VSS 1.42665f
C1242 XRX.XFRONT.XFE_O.XN.t13 VSS 1.43937f
C1243 XRX.XFRONT.XFE_O.XN.t12 VSS 0.33222f
C1244 XRX.XFRONT.XFE_O.XN.t11 VSS 0.33222f
C1245 XRX.XFRONT.XFE_O.XN.n18 VSS 1.05664f
C1246 XRX.XFRONT.XFE_O.XN.n19 VSS 0.59551f
C1247 XRX.XFRONT.XFE_O.XN.t10 VSS 0.33222f
C1248 XRX.XFRONT.XFE_O.XN.t9 VSS 0.33222f
C1249 XRX.XFRONT.XFE_O.XN.n20 VSS 1.05664f
C1250 XRX.XFRONT.XFE_O.XN.n21 VSS 0.31329f
C1251 XRX.XFRONT.XFE_O.XN.t8 VSS 0.33222f
C1252 XRX.XFRONT.XFE_O.XN.t7 VSS 0.33222f
C1253 XRX.XFRONT.XFE_O.XN.n22 VSS 1.05664f
C1254 XRX.XFRONT.XFE_O.XN.n23 VSS 0.25318f
C1255 XRX.XFRONT.XFE_O.XN.t2 VSS 1.43937f
C1256 XRX.XFRONT.XFE_O.XN.t4 VSS 0.33222f
C1257 XRX.XFRONT.XFE_O.XN.t3 VSS 0.33222f
C1258 XRX.XFRONT.XFE_O.XN.n24 VSS 1.05664f
C1259 XRX.XFRONT.XFE_O.XN.n25 VSS 0.59551f
C1260 XRX.XFRONT.XFE_O.XN.t6 VSS 0.33222f
C1261 XRX.XFRONT.XFE_O.XN.t5 VSS 0.33222f
C1262 XRX.XFRONT.XFE_O.XN.n26 VSS 1.05664f
C1263 XRX.XFRONT.XFE_O.XN.n27 VSS 0.25318f
C1264 XRX.XFRONT.XFE_O.XN.n28 VSS 0.85518f
C1265 XRX.XFRONT.XFE_O.XN.n29 VSS 1.72642f
C1266 XRX.XFRONT.XFE_O.XN.t1 VSS 1.48871f
C1267 XRX.XFRONT.XFE_O.XN.t0 VSS 1.47912f
C1268 XRX.XFRONT.XFE_O.XN.n30 VSS 2.31351f
C1269 XRX.XFRONT.XFE_O.XN.n31 VSS 2.80884f
C1270 XRX.XFRONT.XFE_O.XN.t21 VSS 0.30304f
C1271 XRX.XFRONT.XFE_O.XN.t20 VSS 0.30047f
C1272 XRX.XFRONT.XFE_O.XN.n32 VSS 1.07282f
C1273 XRX.XFRONT.XFE_O.XN.t19 VSS 0.30047f
C1274 XRX.XFRONT.XFE_O.XN.t18 VSS 0.30047f
C1275 XRX.XFRONT.XFE_O.XN.n33 VSS 1.06449f
C1276 XRX.XFRONT.XFE_O.XN.t15 VSS 0.30047f
C1277 XRX.XFRONT.XFE_O.XN.t14 VSS 0.30305f
C1278 XRX.XFRONT.XFE_O.XN.n34 VSS 1.07282f
C1279 XRX.XFRONT.XFE_O.XN.t17 VSS 0.30047f
C1280 XRX.XFRONT.XFE_O.XN.t16 VSS 0.30047f
C1281 XRX.XFRONT.XFE_O.XN.n35 VSS 1.06449f
C1282 XRX.XFRONT.XFE_O.XN.n36 VSS 0.53944f
C1283 XRX.XFRONT.XFE_O.XN.n37 VSS 1.44722f
C1284 XRX.XFRONT.XFE_O.XN.n38 VSS 1.69004f
C1285 XRX.XFRONT.XFE_O.XN.n39 VSS 1.44329f
C1286 XRX.XFRONT.XFE_O.XN.n40 VSS 3.21788f
C1287 XRX.XFRONT.XFE_O.XN.n41 VSS 0.24424f
C1288 XRX.XFRONT.XFE_O.XN.n42 VSS 0.25216f
C1289 XRX.XFRONT.XFE_O.XN.n43 VSS 0.25216f
C1290 XRX.XFRONT.XFE_O.XN.n44 VSS 0.18011f
C1291 XRX.XFRONT.XFE_O.XN.n45 VSS 0.49868f
C1292 XRX.XFRONT.XFE_O.XN.n46 VSS 0.16803f
C1293 XRX.XFRONT.XFE_O.XN.n47 VSS 0.33968f
C1294 XRX.XFRONT.XFE_O.XN.n48 VSS 0.18011f
C1295 XRX.XFRONT.XFE_O.XN.n49 VSS 0.11653f
C1296 XRX.XFRONT.XFE_O.XN.n50 VSS 0.11679f
C1297 XRX.XFRONT.XFE_O.XN.n51 VSS 0.11679f
C1298 XRX.XFRONT.XFE_O.XN.n52 VSS 0.11679f
C1299 XRX.XFRONT.XFE_O.XN.n53 VSS 0.11679f
C1300 XRX.XFRONT.XFE_O.XN.n54 VSS 0.18011f
C1301 XRX.XFRONT.XFE_O.XN.n55 VSS 0.25242f
C1302 XRX.XFRONT.XFE_O.XN.n56 VSS 0.25242f
C1303 XRX.XFRONT.XFE_O.XN.n57 VSS 0.25242f
C1304 XRX.XFRONT.XFE_O.XN.n58 VSS 0.25242f
C1305 XRX.XFRONT.XFE_O.XN.n59 VSS 0.25242f
C1306 XRX.XFRONT.XFE_O.XN.n60 VSS 0.49868f
C1307 XRX.XFRONT.XFE_O.XN.n61 VSS 0.16803f
C1308 XRX.XFRONT.XFE_O.XN.n62 VSS 0.33994f
C1309 XRX.XFRONT.XFE_O.XN.n63 VSS 0.18011f
C1310 XRX.XFRONT.XFE_O.XN.n64 VSS 0.18011f
C1311 XRX.XFRONT.XFE_O.XN.n65 VSS 0.18011f
C1312 XRX.XFRONT.XFE_O.XN.n66 VSS 0.18011f
C1313 XRX.XFRONT.XFE_O.XN.n67 VSS 0.18011f
C1314 XRX.XFRONT.XFE_O.XN.n68 VSS 0.18011f
C1315 XRX.XFRONT.XFE_O.XN.n69 VSS 0.18011f
C1316 XRX.XFRONT.XFE_O.XN.n70 VSS 0.29791f
C1317 XRX.XFRONT.XFE_O.XN.n71 VSS 1.89723f
C1318 XRX.XFRONT.XFE_O.XN.n72 VSS 1.11528f
C1319 XRX.XFRONT.XFE_O.XN.n73 VSS 0.17033f
C1320 XRX.XFRONT.XFE_O.XN.n74 VSS 0.16803f
C1321 XRX.XFRONT.XFE_O.XN.n75 VSS 0.18011f
C1322 XRX.XFRONT.XFE_O.XN.n76 VSS 0.18011f
C1323 XRX.XFRONT.XFE_O.XN.n77 VSS 0.32954f
C1324 XRX.XFRONT.XFE_O.XN.n78 VSS 1.2398f
C1325 XRX.XFRONT.XFE_O.XN.n79 VSS 1.90891f
C1326 XRX.XFRONT.XFE_O.XP.n0 VSS 0.33737f
C1327 XRX.XFRONT.XFE_O.XP.n1 VSS 0.16675f
C1328 XRX.XFRONT.XFE_O.XP.n2 VSS 0.17874f
C1329 XRX.XFRONT.XFE_O.XP.n3 VSS 0.17874f
C1330 XRX.XFRONT.XFE_O.XP.n4 VSS 0.16893f
C1331 XRX.XFRONT.XFE_O.XP.n5 VSS 1.42089f
C1332 XRX.XFRONT.XFE_O.XP.n6 VSS 0.24239f
C1333 XRX.XFRONT.XFE_O.XP.n7 VSS 0.25025f
C1334 XRX.XFRONT.XFE_O.XP.n8 VSS 0.25025f
C1335 XRX.XFRONT.XFE_O.XP.n9 VSS 0.17874f
C1336 XRX.XFRONT.XFE_O.XP.n10 VSS 0.4949f
C1337 XRX.XFRONT.XFE_O.XP.n11 VSS 0.16675f
C1338 XRX.XFRONT.XFE_O.XP.n12 VSS 0.3371f
C1339 XRX.XFRONT.XFE_O.XP.n13 VSS 0.17874f
C1340 XRX.XFRONT.XFE_O.XP.n14 VSS 0.11565f
C1341 XRX.XFRONT.XFE_O.XP.n15 VSS 0.11591f
C1342 XRX.XFRONT.XFE_O.XP.n16 VSS 0.11591f
C1343 XRX.XFRONT.XFE_O.XP.n17 VSS 0.11591f
C1344 XRX.XFRONT.XFE_O.XP.n18 VSS 0.11591f
C1345 XRX.XFRONT.XFE_O.XP.n19 VSS 0.17874f
C1346 XRX.XFRONT.XFE_O.XP.n20 VSS 0.25051f
C1347 XRX.XFRONT.XFE_O.XP.n21 VSS 0.25051f
C1348 XRX.XFRONT.XFE_O.XP.n22 VSS 0.25051f
C1349 XRX.XFRONT.XFE_O.XP.n23 VSS 0.25051f
C1350 XRX.XFRONT.XFE_O.XP.n24 VSS 0.25051f
C1351 XRX.XFRONT.XFE_O.XP.n25 VSS 0.4949f
C1352 XRX.XFRONT.XFE_O.XP.n26 VSS 0.16675f
C1353 XRX.XFRONT.XFE_O.XP.n27 VSS 0.33737f
C1354 XRX.XFRONT.XFE_O.XP.n28 VSS 0.17874f
C1355 XRX.XFRONT.XFE_O.XP.n29 VSS 0.17874f
C1356 XRX.XFRONT.XFE_O.XP.n30 VSS 0.17874f
C1357 XRX.XFRONT.XFE_O.XP.n31 VSS 0.17874f
C1358 XRX.XFRONT.XFE_O.XP.n32 VSS 0.17874f
C1359 XRX.XFRONT.XFE_O.XP.n33 VSS 0.17874f
C1360 XRX.XFRONT.XFE_O.XP.n34 VSS 0.17874f
C1361 XRX.XFRONT.XFE_O.XP.n35 VSS 0.29566f
C1362 XRX.XFRONT.XFE_O.XP.n36 VSS 1.795f
C1363 XRX.XFRONT.XFE_O.XP.n37 VSS 3.10172f
C1364 XRX.XFRONT.XFE_O.XP.n38 VSS 1.47542f
C1365 XRX.XFRONT.XFE_O.XP.n39 VSS 3.45737f
C1366 XRX.XFRONT.XFE_O.XP.t20 VSS 1.39935f
C1367 XRX.XFRONT.XFE_O.XP.t19 VSS 0.29892f
C1368 XRX.XFRONT.XFE_O.XP.t18 VSS 0.29892f
C1369 XRX.XFRONT.XFE_O.XP.n40 VSS 1.05643f
C1370 XRX.XFRONT.XFE_O.XP.n41 VSS 0.58069f
C1371 XRX.XFRONT.XFE_O.XP.t24 VSS 0.29892f
C1372 XRX.XFRONT.XFE_O.XP.t23 VSS 0.29892f
C1373 XRX.XFRONT.XFE_O.XP.n42 VSS 1.05643f
C1374 XRX.XFRONT.XFE_O.XP.n43 VSS 0.24348f
C1375 XRX.XFRONT.XFE_O.XP.t25 VSS 1.39936f
C1376 XRX.XFRONT.XFE_O.XP.t22 VSS 0.29892f
C1377 XRX.XFRONT.XFE_O.XP.t21 VSS 0.29892f
C1378 XRX.XFRONT.XFE_O.XP.n44 VSS 1.05643f
C1379 XRX.XFRONT.XFE_O.XP.n45 VSS 0.52103f
C1380 XRX.XFRONT.XFE_O.XP.n46 VSS 1.37228f
C1381 XRX.XFRONT.XFE_O.XP.n47 VSS 2.05638f
C1382 XRX.XFRONT.XFE_O.XP.t29 VSS 1.47329f
C1383 XRX.XFRONT.XFE_O.XP.t30 VSS 1.47571f
C1384 XRX.XFRONT.XFE_O.XP.n48 VSS 2.36091f
C1385 XRX.XFRONT.XFE_O.XP.n49 VSS 2.92298f
C1386 XRX.XFRONT.XFE_O.XP.t26 VSS 1.43044f
C1387 XRX.XFRONT.XFE_O.XP.t27 VSS 0.33163f
C1388 XRX.XFRONT.XFE_O.XP.t28 VSS 0.33163f
C1389 XRX.XFRONT.XFE_O.XP.n50 VSS 1.04864f
C1390 XRX.XFRONT.XFE_O.XP.n51 VSS 0.591f
C1391 XRX.XFRONT.XFE_O.XP.t4 VSS 0.33163f
C1392 XRX.XFRONT.XFE_O.XP.t5 VSS 0.33163f
C1393 XRX.XFRONT.XFE_O.XP.n52 VSS 1.04864f
C1394 XRX.XFRONT.XFE_O.XP.n53 VSS 0.31092f
C1395 XRX.XFRONT.XFE_O.XP.t6 VSS 0.33163f
C1396 XRX.XFRONT.XFE_O.XP.t7 VSS 0.33163f
C1397 XRX.XFRONT.XFE_O.XP.n54 VSS 1.04864f
C1398 XRX.XFRONT.XFE_O.XP.n55 VSS 0.25126f
C1399 XRX.XFRONT.XFE_O.XP.t31 VSS 1.43044f
C1400 XRX.XFRONT.XFE_O.XP.t2 VSS 0.33163f
C1401 XRX.XFRONT.XFE_O.XP.t3 VSS 0.33163f
C1402 XRX.XFRONT.XFE_O.XP.n56 VSS 1.04864f
C1403 XRX.XFRONT.XFE_O.XP.n57 VSS 0.591f
C1404 XRX.XFRONT.XFE_O.XP.t0 VSS 0.33163f
C1405 XRX.XFRONT.XFE_O.XP.t1 VSS 0.33163f
C1406 XRX.XFRONT.XFE_O.XP.n58 VSS 1.04864f
C1407 XRX.XFRONT.XFE_O.XP.n59 VSS 0.25126f
C1408 XRX.XFRONT.XFE_O.XP.n60 VSS 0.78552f
C1409 XRX.XFRONT.XFE_O.XP.n61 VSS 1.62307f
C1410 XRX.XFRONT.XFE_O.XP.n62 VSS 0.95385f
C1411 XRX.XFRONT.XFE_O.XP.n63 VSS 1.25315f
C1412 XRX.XFRONT.XFE_O.XP.n64 VSS 0.16904f
C1413 XRX.XFRONT.XFE_O.XP.n65 VSS 0.16675f
C1414 XRX.XFRONT.XFE_O.XP.n66 VSS 0.17874f
C1415 XRX.XFRONT.XFE_O.XP.n67 VSS 0.17874f
C1416 XRX.XFRONT.XFE_O.XP.n68 VSS 0.32704f
C1417 XRX.XFRONT.XFE_O.XP.n69 VSS 0.42062f
C1418 XRX.XFRONT.XFE_O.XP.n70 VSS 0.87173f
C1419 XRX.XFRONT.XFE_O.XP.t17 VSS 1.39936f
C1420 XRX.XFRONT.XFE_O.XP.t16 VSS 0.29892f
C1421 XRX.XFRONT.XFE_O.XP.t15 VSS 0.29892f
C1422 XRX.XFRONT.XFE_O.XP.n71 VSS 1.05643f
C1423 XRX.XFRONT.XFE_O.XP.n72 VSS 0.58069f
C1424 XRX.XFRONT.XFE_O.XP.t14 VSS 0.29892f
C1425 XRX.XFRONT.XFE_O.XP.t13 VSS 0.29892f
C1426 XRX.XFRONT.XFE_O.XP.n73 VSS 1.05643f
C1427 XRX.XFRONT.XFE_O.XP.n74 VSS 0.30313f
C1428 XRX.XFRONT.XFE_O.XP.t12 VSS 0.29892f
C1429 XRX.XFRONT.XFE_O.XP.t11 VSS 0.29892f
C1430 XRX.XFRONT.XFE_O.XP.n75 VSS 1.05643f
C1431 XRX.XFRONT.XFE_O.XP.n76 VSS 0.30313f
C1432 XRX.XFRONT.XFE_O.XP.t10 VSS 0.29892f
C1433 XRX.XFRONT.XFE_O.XP.t9 VSS 0.29892f
C1434 XRX.XFRONT.XFE_O.XP.n77 VSS 1.05643f
C1435 XRX.XFRONT.XFE_O.XP.n78 VSS 0.28822f
C1436 XRX.XFRONT.XFE_O.XP.t8 VSS 1.38807f
C1437 XRX.XFRONT.XFE_O.XP.n79 VSS 1.55413f
C1438 XRX.XFRONT.XFE_O.XP.n80 VSS 1.56891f
C1439 XRX.XFRONT.XFE_E.HB.n0 VSS 0.2398f
C1440 XRX.XFRONT.XFE_E.HB.n1 VSS 0.11853f
C1441 XRX.XFRONT.XFE_E.HB.n2 VSS 0.12705f
C1442 XRX.XFRONT.XFE_E.HB.n3 VSS 0.12705f
C1443 XRX.XFRONT.XFE_E.HB.n4 VSS 0.12008f
C1444 XRX.XFRONT.XFE_E.HB.n5 VSS 0.46053f
C1445 XRX.XFRONT.XFE_E.HB.n6 VSS 0.11853f
C1446 XRX.XFRONT.XFE_E.HB.n7 VSS 0.12705f
C1447 XRX.XFRONT.XFE_E.HB.n8 VSS 0.12008f
C1448 XRX.XFRONT.XFE_E.HB.n9 VSS 0.67097f
C1449 XRX.XFRONT.XFE_E.HB.n10 VSS 0.12015f
C1450 XRX.XFRONT.XFE_E.HB.n11 VSS 0.11853f
C1451 XRX.XFRONT.XFE_E.HB.n12 VSS 0.12705f
C1452 XRX.XFRONT.XFE_E.HB.n13 VSS 0.12705f
C1453 XRX.XFRONT.XFE_E.HB.n14 VSS 0.23246f
C1454 XRX.XFRONT.XFE_E.HB.n15 VSS 0.2663f
C1455 XRX.XFRONT.XFE_E.HB.n16 VSS 1.55603f
C1456 XRX.XFRONT.XFE_E.HB.t14 VSS 0.995f
C1457 XRX.XFRONT.XFE_E.HB.t13 VSS 0.21453f
C1458 XRX.XFRONT.XFE_E.HB.t12 VSS 0.21453f
C1459 XRX.XFRONT.XFE_E.HB.n17 VSS 0.74539f
C1460 XRX.XFRONT.XFE_E.HB.n18 VSS 0.37768f
C1461 XRX.XFRONT.XFE_E.HB.t7 VSS 0.99499f
C1462 XRX.XFRONT.XFE_E.HB.t9 VSS 0.21453f
C1463 XRX.XFRONT.XFE_E.HB.t8 VSS 0.21453f
C1464 XRX.XFRONT.XFE_E.HB.n19 VSS 0.74539f
C1465 XRX.XFRONT.XFE_E.HB.n20 VSS 0.42009f
C1466 XRX.XFRONT.XFE_E.HB.t11 VSS 0.21453f
C1467 XRX.XFRONT.XFE_E.HB.t10 VSS 0.21453f
C1468 XRX.XFRONT.XFE_E.HB.n21 VSS 0.74539f
C1469 XRX.XFRONT.XFE_E.HB.n22 VSS 0.1786f
C1470 XRX.XFRONT.XFE_E.HB.n23 VSS 0.17978f
C1471 XRX.XFRONT.XFE_E.HB.n24 VSS 0.85854f
C1472 XRX.XFRONT.XFE_E.HB.t4 VSS 1.04006f
C1473 XRX.XFRONT.XFE_E.HB.t1 VSS 1.04186f
C1474 XRX.XFRONT.XFE_E.HB.t3 VSS 0.26148f
C1475 XRX.XFRONT.XFE_E.HB.t2 VSS 0.26148f
C1476 XRX.XFRONT.XFE_E.HB.n25 VSS 0.75093f
C1477 XRX.XFRONT.XFE_E.HB.n26 VSS 0.37035f
C1478 XRX.XFRONT.XFE_E.HB.n27 VSS 0.88409f
C1479 XRX.XFRONT.XFE_E.HB.n28 VSS 0.92912f
C1480 XRX.XFRONT.XFE_E.HB.t0 VSS 1.31404f
C1481 XRX.XFRONT.XFE_E.HB.n29 VSS 0.72746f
C1482 XRX.XFRONT.XFE_E.HB.t15 VSS 1.10226f
C1483 XRX.XFRONT.XFE_E.HB.t16 VSS 0.31856f
C1484 XRX.XFRONT.XFE_E.HB.t5 VSS 0.31856f
C1485 XRX.XFRONT.XFE_E.HB.n30 VSS 0.75093f
C1486 XRX.XFRONT.XFE_E.HB.n31 VSS 0.33855f
C1487 XRX.XFRONT.XFE_E.HB.t6 VSS 1.09781f
C1488 XRX.XFRONT.XFE_E.HB.n32 VSS 1.68299f
C1489 XRX.XFRONT.XFE_E.HB.n33 VSS 3.98342f
C1490 XRX.XFRONT.XFE_E.HB.n34 VSS 3.12293f
C1491 XRX.XFRONT.XFE_E.H.n0 VSS 0.11342f
C1492 XRX.XFRONT.XFE_E.H.n1 VSS 0.11189f
C1493 XRX.XFRONT.XFE_E.H.n2 VSS 0.11993f
C1494 XRX.XFRONT.XFE_E.H.n3 VSS 0.11993f
C1495 XRX.XFRONT.XFE_E.H.n4 VSS 0.21944f
C1496 XRX.XFRONT.XFE_E.H.n5 VSS 0.22162f
C1497 XRX.XFRONT.XFE_E.H.n6 VSS 0.21944f
C1498 XRX.XFRONT.XFE_E.H.n7 VSS 0.11189f
C1499 XRX.XFRONT.XFE_E.H.n8 VSS 0.11993f
C1500 XRX.XFRONT.XFE_E.H.n9 VSS 0.11993f
C1501 XRX.XFRONT.XFE_E.H.n10 VSS 0.11342f
C1502 XRX.XFRONT.XFE_E.H.n11 VSS 0.44107f
C1503 XRX.XFRONT.XFE_E.H.n12 VSS 3.43313f
C1504 XRX.XFRONT.XFE_E.H.t14 VSS 1.04796f
C1505 XRX.XFRONT.XFE_E.H.t1 VSS 1.04841f
C1506 XRX.XFRONT.XFE_E.H.t15 VSS 0.31176f
C1507 XRX.XFRONT.XFE_E.H.t0 VSS 0.31176f
C1508 XRX.XFRONT.XFE_E.H.n13 VSS 0.70885f
C1509 XRX.XFRONT.XFE_E.H.n14 VSS 0.3496f
C1510 XRX.XFRONT.XFE_E.H.n15 VSS 1.60381f
C1511 XRX.XFRONT.XFE_E.H.n16 VSS 3.91167f
C1512 XRX.XFRONT.XFE_E.H.t16 VSS 1.22975f
C1513 XRX.XFRONT.XFE_E.H.n17 VSS 0.73537f
C1514 XRX.XFRONT.XFE_E.H.t13 VSS 0.99312f
C1515 XRX.XFRONT.XFE_E.H.t12 VSS 0.99928f
C1516 XRX.XFRONT.XFE_E.H.t10 VSS 0.26026f
C1517 XRX.XFRONT.XFE_E.H.t11 VSS 0.26026f
C1518 XRX.XFRONT.XFE_E.H.n18 VSS 0.70885f
C1519 XRX.XFRONT.XFE_E.H.n19 VSS 0.3496f
C1520 XRX.XFRONT.XFE_E.H.n20 VSS 0.87696f
C1521 XRX.XFRONT.XFE_E.H.n21 VSS 0.88918f
C1522 XRX.XFRONT.XFE_E.H.t9 VSS 0.94461f
C1523 XRX.XFRONT.XFE_E.H.t8 VSS 0.20773f
C1524 XRX.XFRONT.XFE_E.H.t7 VSS 0.20773f
C1525 XRX.XFRONT.XFE_E.H.n22 VSS 0.70363f
C1526 XRX.XFRONT.XFE_E.H.n23 VSS 0.35652f
C1527 XRX.XFRONT.XFE_E.H.t2 VSS 0.94461f
C1528 XRX.XFRONT.XFE_E.H.t4 VSS 0.20773f
C1529 XRX.XFRONT.XFE_E.H.t3 VSS 0.20773f
C1530 XRX.XFRONT.XFE_E.H.n24 VSS 0.70363f
C1531 XRX.XFRONT.XFE_E.H.n25 VSS 0.39655f
C1532 XRX.XFRONT.XFE_E.H.t6 VSS 0.20773f
C1533 XRX.XFRONT.XFE_E.H.t5 VSS 0.20773f
C1534 XRX.XFRONT.XFE_E.H.n26 VSS 0.70363f
C1535 XRX.XFRONT.XFE_E.H.n27 VSS 0.1686f
C1536 XRX.XFRONT.XFE_E.H.n28 VSS 0.2121f
C1537 XRX.XFRONT.XFE_E.H.n29 VSS 0.7741f
C1538 XRX.XFRONT.XFE_E.H.n30 VSS 0.11189f
C1539 XRX.XFRONT.XFE_E.H.n31 VSS 0.11993f
C1540 XRX.XFRONT.XFE_E.H.n32 VSS 0.11335f
C1541 XRX.XFRONT.XFE_E.H.n33 VSS 0.64427f
C1542 XRX.XFRONT.XFE_E.H.n34 VSS 1.07962f
C1543 XRX.XFRONT.XFE_O.H.n0 VSS 0.11342f
C1544 XRX.XFRONT.XFE_O.H.n1 VSS 0.11189f
C1545 XRX.XFRONT.XFE_O.H.n2 VSS 0.11993f
C1546 XRX.XFRONT.XFE_O.H.n3 VSS 0.11993f
C1547 XRX.XFRONT.XFE_O.H.n4 VSS 0.21944f
C1548 XRX.XFRONT.XFE_O.H.n5 VSS 0.44107f
C1549 XRX.XFRONT.XFE_O.H.n6 VSS 3.43312f
C1550 XRX.XFRONT.XFE_O.H.t16 VSS 1.04841f
C1551 XRX.XFRONT.XFE_O.H.t13 VSS 0.31176f
C1552 XRX.XFRONT.XFE_O.H.t14 VSS 0.31176f
C1553 XRX.XFRONT.XFE_O.H.n7 VSS 0.70885f
C1554 XRX.XFRONT.XFE_O.H.n8 VSS 0.3496f
C1555 XRX.XFRONT.XFE_O.H.t15 VSS 1.04796f
C1556 XRX.XFRONT.XFE_O.H.n9 VSS 1.60381f
C1557 XRX.XFRONT.XFE_O.H.n10 VSS 3.91167f
C1558 XRX.XFRONT.XFE_O.H.t0 VSS 1.22975f
C1559 XRX.XFRONT.XFE_O.H.n11 VSS 0.73537f
C1560 XRX.XFRONT.XFE_O.H.t4 VSS 0.99928f
C1561 XRX.XFRONT.XFE_O.H.t3 VSS 0.26026f
C1562 XRX.XFRONT.XFE_O.H.t2 VSS 0.26026f
C1563 XRX.XFRONT.XFE_O.H.n12 VSS 0.70885f
C1564 XRX.XFRONT.XFE_O.H.n13 VSS 0.3496f
C1565 XRX.XFRONT.XFE_O.H.t1 VSS 0.99312f
C1566 XRX.XFRONT.XFE_O.H.n14 VSS 0.87696f
C1567 XRX.XFRONT.XFE_O.H.n15 VSS 0.88918f
C1568 XRX.XFRONT.XFE_O.H.t12 VSS 0.94461f
C1569 XRX.XFRONT.XFE_O.H.t11 VSS 0.20773f
C1570 XRX.XFRONT.XFE_O.H.t10 VSS 0.20773f
C1571 XRX.XFRONT.XFE_O.H.n16 VSS 0.70362f
C1572 XRX.XFRONT.XFE_O.H.n17 VSS 0.39655f
C1573 XRX.XFRONT.XFE_O.H.t9 VSS 0.20773f
C1574 XRX.XFRONT.XFE_O.H.t8 VSS 0.20773f
C1575 XRX.XFRONT.XFE_O.H.n18 VSS 0.70362f
C1576 XRX.XFRONT.XFE_O.H.n19 VSS 0.1686f
C1577 XRX.XFRONT.XFE_O.H.t5 VSS 0.94461f
C1578 XRX.XFRONT.XFE_O.H.t7 VSS 0.20773f
C1579 XRX.XFRONT.XFE_O.H.t6 VSS 0.20773f
C1580 XRX.XFRONT.XFE_O.H.n20 VSS 0.70362f
C1581 XRX.XFRONT.XFE_O.H.n21 VSS 0.35652f
C1582 XRX.XFRONT.XFE_O.H.n22 VSS 0.2121f
C1583 XRX.XFRONT.XFE_O.H.n23 VSS 0.7741f
C1584 XRX.XFRONT.XFE_O.H.n24 VSS 0.11189f
C1585 XRX.XFRONT.XFE_O.H.n25 VSS 0.11993f
C1586 XRX.XFRONT.XFE_O.H.n26 VSS 0.11335f
C1587 XRX.XFRONT.XFE_O.H.n27 VSS 0.64427f
C1588 XRX.XFRONT.XFE_O.H.n28 VSS 1.08568f
C1589 XRX.XFRONT.XFE_O.H.n29 VSS 0.21944f
C1590 XRX.XFRONT.XFE_O.H.n30 VSS 0.11189f
C1591 XRX.XFRONT.XFE_O.H.n31 VSS 0.11993f
C1592 XRX.XFRONT.XFE_O.H.n32 VSS 0.11993f
C1593 XRX.XFRONT.XFE_O.H.n33 VSS 0.11342f
C1594 XRX.XFRONT.XFE_O.H.n34 VSS 0.22097f
C1595 XRX.XFRONT.XFE_O.H.n35 VSS 0.30698f
C1596 XRX.XFRONT.XFE_O.HB.n0 VSS 0.11853f
C1597 XRX.XFRONT.XFE_O.HB.n1 VSS 0.12705f
C1598 XRX.XFRONT.XFE_O.HB.n2 VSS 0.12008f
C1599 XRX.XFRONT.XFE_O.HB.n3 VSS 0.67097f
C1600 XRX.XFRONT.XFE_O.HB.n4 VSS 0.23246f
C1601 XRX.XFRONT.XFE_O.HB.n5 VSS 0.11853f
C1602 XRX.XFRONT.XFE_O.HB.n6 VSS 0.12705f
C1603 XRX.XFRONT.XFE_O.HB.n7 VSS 0.12705f
C1604 XRX.XFRONT.XFE_O.HB.n8 VSS 0.12015f
C1605 XRX.XFRONT.XFE_O.HB.n9 VSS 0.2663f
C1606 XRX.XFRONT.XFE_O.HB.n10 VSS 1.55603f
C1607 XRX.XFRONT.XFE_O.HB.t9 VSS 0.99499f
C1608 XRX.XFRONT.XFE_O.HB.t8 VSS 0.21453f
C1609 XRX.XFRONT.XFE_O.HB.t7 VSS 0.21453f
C1610 XRX.XFRONT.XFE_O.HB.n11 VSS 0.74539f
C1611 XRX.XFRONT.XFE_O.HB.n12 VSS 0.42009f
C1612 XRX.XFRONT.XFE_O.HB.t6 VSS 0.21453f
C1613 XRX.XFRONT.XFE_O.HB.t5 VSS 0.21453f
C1614 XRX.XFRONT.XFE_O.HB.n13 VSS 0.74539f
C1615 XRX.XFRONT.XFE_O.HB.n14 VSS 0.1786f
C1616 XRX.XFRONT.XFE_O.HB.t2 VSS 0.995f
C1617 XRX.XFRONT.XFE_O.HB.t4 VSS 0.21453f
C1618 XRX.XFRONT.XFE_O.HB.t3 VSS 0.21453f
C1619 XRX.XFRONT.XFE_O.HB.n15 VSS 0.74539f
C1620 XRX.XFRONT.XFE_O.HB.n16 VSS 0.37768f
C1621 XRX.XFRONT.XFE_O.HB.n17 VSS 0.17978f
C1622 XRX.XFRONT.XFE_O.HB.n18 VSS 0.85854f
C1623 XRX.XFRONT.XFE_O.HB.t0 VSS 1.04186f
C1624 XRX.XFRONT.XFE_O.HB.t11 VSS 0.26148f
C1625 XRX.XFRONT.XFE_O.HB.t12 VSS 0.26148f
C1626 XRX.XFRONT.XFE_O.HB.n19 VSS 0.75092f
C1627 XRX.XFRONT.XFE_O.HB.n20 VSS 0.37035f
C1628 XRX.XFRONT.XFE_O.HB.t13 VSS 1.04006f
C1629 XRX.XFRONT.XFE_O.HB.n21 VSS 0.88409f
C1630 XRX.XFRONT.XFE_O.HB.n22 VSS 0.92912f
C1631 XRX.XFRONT.XFE_O.HB.t10 VSS 1.31404f
C1632 XRX.XFRONT.XFE_O.HB.n23 VSS 0.72746f
C1633 XRX.XFRONT.XFE_O.HB.t14 VSS 1.09781f
C1634 XRX.XFRONT.XFE_O.HB.t1 VSS 1.10226f
C1635 XRX.XFRONT.XFE_O.HB.t15 VSS 0.31856f
C1636 XRX.XFRONT.XFE_O.HB.t16 VSS 0.31856f
C1637 XRX.XFRONT.XFE_O.HB.n24 VSS 0.75092f
C1638 XRX.XFRONT.XFE_O.HB.n25 VSS 0.33855f
C1639 XRX.XFRONT.XFE_O.HB.n26 VSS 1.68299f
C1640 XRX.XFRONT.XFE_O.HB.n27 VSS 3.98342f
C1641 XRX.XFRONT.XFE_O.HB.n28 VSS 3.12935f
C1642 XRX.XFRONT.XFE_O.HB.n29 VSS 0.2398f
C1643 XRX.XFRONT.XFE_O.HB.n30 VSS 0.11853f
C1644 XRX.XFRONT.XFE_O.HB.n31 VSS 0.12705f
C1645 XRX.XFRONT.XFE_O.HB.n32 VSS 0.12705f
C1646 XRX.XFRONT.XFE_O.HB.n33 VSS 0.12008f
C1647 XRX.XFRONT.XFE_O.HB.n34 VSS 0.4592f
C1648 XRX.XFRONT.XFE_O.HB.n35 VSS 0.70771f
C1649 XRX.XFRONT.XFE_E.NIN.t10 VSS 1.60759f
C1650 XRX.XFRONT.XFE_E.NIN.t9 VSS 0.30317f
C1651 XRX.XFRONT.XFE_E.NIN.t8 VSS 0.30317f
C1652 XRX.XFRONT.XFE_E.NIN.n0 VSS 1.24724f
C1653 XRX.XFRONT.XFE_E.NIN.n1 VSS 0.63197f
C1654 XRX.XFRONT.XFE_E.NIN.t3 VSS 1.6076f
C1655 XRX.XFRONT.XFE_E.NIN.t5 VSS 0.30317f
C1656 XRX.XFRONT.XFE_E.NIN.t4 VSS 0.30317f
C1657 XRX.XFRONT.XFE_E.NIN.n2 VSS 1.24724f
C1658 XRX.XFRONT.XFE_E.NIN.n3 VSS 0.70293f
C1659 XRX.XFRONT.XFE_E.NIN.t7 VSS 0.30317f
C1660 XRX.XFRONT.XFE_E.NIN.t6 VSS 0.30317f
C1661 XRX.XFRONT.XFE_E.NIN.n4 VSS 1.24724f
C1662 XRX.XFRONT.XFE_E.NIN.n5 VSS 0.29885f
C1663 XRX.XFRONT.XFE_E.NIN.n6 VSS 0.9909f
C1664 XRX.XFRONT.XFE_E.NIN.t22 VSS 0.37276f
C1665 XRX.XFRONT.XFE_E.NIN.t23 VSS 0.36932f
C1666 XRX.XFRONT.XFE_E.NIN.n7 VSS 1.25728f
C1667 XRX.XFRONT.XFE_E.NIN.t11 VSS 0.36932f
C1668 XRX.XFRONT.XFE_E.NIN.t12 VSS 0.36932f
C1669 XRX.XFRONT.XFE_E.NIN.n8 VSS 1.24724f
C1670 XRX.XFRONT.XFE_E.NIN.n9 VSS 0.65507f
C1671 XRX.XFRONT.XFE_E.NIN.t13 VSS 0.36932f
C1672 XRX.XFRONT.XFE_E.NIN.t0 VSS 0.36932f
C1673 XRX.XFRONT.XFE_E.NIN.n10 VSS 1.24724f
C1674 XRX.XFRONT.XFE_E.NIN.n11 VSS 0.36981f
C1675 XRX.XFRONT.XFE_E.NIN.t1 VSS 0.36932f
C1676 XRX.XFRONT.XFE_E.NIN.t2 VSS 0.36932f
C1677 XRX.XFRONT.XFE_E.NIN.n12 VSS 1.24724f
C1678 XRX.XFRONT.XFE_E.NIN.t17 VSS 0.36932f
C1679 XRX.XFRONT.XFE_E.NIN.t14 VSS 0.37276f
C1680 XRX.XFRONT.XFE_E.NIN.n13 VSS 1.25728f
C1681 XRX.XFRONT.XFE_E.NIN.t15 VSS 0.36932f
C1682 XRX.XFRONT.XFE_E.NIN.t16 VSS 0.36932f
C1683 XRX.XFRONT.XFE_E.NIN.n14 VSS 1.24724f
C1684 XRX.XFRONT.XFE_E.NIN.n15 VSS 0.65507f
C1685 XRX.XFRONT.XFE_E.NIN.n16 VSS 1.00904f
C1686 XRX.XFRONT.XFE_E.NIN.t21 VSS 1.67426f
C1687 XRX.XFRONT.XFE_E.NIN.t18 VSS 1.6785f
C1688 XRX.XFRONT.XFE_E.NIN.t20 VSS 0.37271f
C1689 XRX.XFRONT.XFE_E.NIN.t19 VSS 0.37271f
C1690 XRX.XFRONT.XFE_E.NIN.n17 VSS 1.25651f
C1691 XRX.XFRONT.XFE_E.NIN.n18 VSS 0.61971f
C1692 XRX.XFRONT.XFE_E.NIN.n19 VSS 3.4549f
C1693 XRX.XFRONT.XFE_E.NIN.n20 VSS 4.90308f
C1694 XRX.XFRONT.XFE_E.NIP.t11 VSS 0.37035f
C1695 XRX.XFRONT.XFE_E.NIP.t12 VSS 0.36688f
C1696 XRX.XFRONT.XFE_E.NIP.n0 VSS 1.23967f
C1697 XRX.XFRONT.XFE_E.NIP.t13 VSS 0.36688f
C1698 XRX.XFRONT.XFE_E.NIP.t8 VSS 0.36688f
C1699 XRX.XFRONT.XFE_E.NIP.n1 VSS 1.22977f
C1700 XRX.XFRONT.XFE_E.NIP.n2 VSS 0.6459f
C1701 XRX.XFRONT.XFE_E.NIP.t9 VSS 0.36688f
C1702 XRX.XFRONT.XFE_E.NIP.t10 VSS 0.36688f
C1703 XRX.XFRONT.XFE_E.NIP.n3 VSS 1.22977f
C1704 XRX.XFRONT.XFE_E.NIP.n4 VSS 0.36463f
C1705 XRX.XFRONT.XFE_E.NIP.t14 VSS 0.36688f
C1706 XRX.XFRONT.XFE_E.NIP.t15 VSS 0.36688f
C1707 XRX.XFRONT.XFE_E.NIP.n5 VSS 1.22977f
C1708 XRX.XFRONT.XFE_E.NIP.t22 VSS 0.36688f
C1709 XRX.XFRONT.XFE_E.NIP.t23 VSS 0.37035f
C1710 XRX.XFRONT.XFE_E.NIP.n6 VSS 1.23967f
C1711 XRX.XFRONT.XFE_E.NIP.t16 VSS 0.36688f
C1712 XRX.XFRONT.XFE_E.NIP.t21 VSS 0.36688f
C1713 XRX.XFRONT.XFE_E.NIP.n7 VSS 1.22977f
C1714 XRX.XFRONT.XFE_E.NIP.n8 VSS 0.6459f
C1715 XRX.XFRONT.XFE_E.NIP.n9 VSS 0.93638f
C1716 XRX.XFRONT.XFE_E.NIP.t7 VSS 1.57837f
C1717 XRX.XFRONT.XFE_E.NIP.t6 VSS 0.29239f
C1718 XRX.XFRONT.XFE_E.NIP.t5 VSS 0.29239f
C1719 XRX.XFRONT.XFE_E.NIP.n10 VSS 1.22977f
C1720 XRX.XFRONT.XFE_E.NIP.n11 VSS 0.62312f
C1721 XRX.XFRONT.XFE_E.NIP.t0 VSS 1.57836f
C1722 XRX.XFRONT.XFE_E.NIP.t2 VSS 0.29239f
C1723 XRX.XFRONT.XFE_E.NIP.t1 VSS 0.29239f
C1724 XRX.XFRONT.XFE_E.NIP.n12 VSS 1.22977f
C1725 XRX.XFRONT.XFE_E.NIP.n13 VSS 0.69308f
C1726 XRX.XFRONT.XFE_E.NIP.t4 VSS 0.29239f
C1727 XRX.XFRONT.XFE_E.NIP.t3 VSS 0.29239f
C1728 XRX.XFRONT.XFE_E.NIP.n14 VSS 1.22977f
C1729 XRX.XFRONT.XFE_E.NIP.n15 VSS 0.29467f
C1730 XRX.XFRONT.XFE_E.NIP.n16 VSS 1.25236f
C1731 XRX.XFRONT.XFE_E.NIP.t20 VSS 1.65266f
C1732 XRX.XFRONT.XFE_E.NIP.t17 VSS 1.65681f
C1733 XRX.XFRONT.XFE_E.NIP.t19 VSS 0.36931f
C1734 XRX.XFRONT.XFE_E.NIP.t18 VSS 0.36931f
C1735 XRX.XFRONT.XFE_E.NIP.n17 VSS 1.23891f
C1736 XRX.XFRONT.XFE_E.NIP.n18 VSS 0.61102f
C1737 XRX.XFRONT.XFE_E.NIP.n19 VSS 3.48061f
C1738 XRX.XFRONT.XFE_E.NIP.n20 VSS 5.15681f
C1739 XRX.XFRONT.XFE_O.NIP.t19 VSS 1.57832f
C1740 XRX.XFRONT.XFE_O.NIP.t18 VSS 0.29235f
C1741 XRX.XFRONT.XFE_O.NIP.t17 VSS 0.29235f
C1742 XRX.XFRONT.XFE_O.NIP.n0 VSS 1.22977f
C1743 XRX.XFRONT.XFE_O.NIP.n1 VSS 0.69308f
C1744 XRX.XFRONT.XFE_O.NIP.t16 VSS 0.29235f
C1745 XRX.XFRONT.XFE_O.NIP.t15 VSS 0.29235f
C1746 XRX.XFRONT.XFE_O.NIP.n2 VSS 1.22977f
C1747 XRX.XFRONT.XFE_O.NIP.n3 VSS 0.29467f
C1748 XRX.XFRONT.XFE_O.NIP.t12 VSS 1.57832f
C1749 XRX.XFRONT.XFE_O.NIP.t14 VSS 0.29235f
C1750 XRX.XFRONT.XFE_O.NIP.t13 VSS 0.29235f
C1751 XRX.XFRONT.XFE_O.NIP.n4 VSS 1.22977f
C1752 XRX.XFRONT.XFE_O.NIP.n5 VSS 0.62312f
C1753 XRX.XFRONT.XFE_O.NIP.n6 VSS 1.25236f
C1754 XRX.XFRONT.XFE_O.NIP.t11 VSS 1.65681f
C1755 XRX.XFRONT.XFE_O.NIP.t10 VSS 0.36931f
C1756 XRX.XFRONT.XFE_O.NIP.t9 VSS 0.36931f
C1757 XRX.XFRONT.XFE_O.NIP.n7 VSS 1.23891f
C1758 XRX.XFRONT.XFE_O.NIP.n8 VSS 0.61102f
C1759 XRX.XFRONT.XFE_O.NIP.t8 VSS 1.65266f
C1760 XRX.XFRONT.XFE_O.NIP.n9 VSS 3.48061f
C1761 XRX.XFRONT.XFE_O.NIP.n10 VSS 5.1674f
C1762 XRX.XFRONT.XFE_O.NIP.t20 VSS 0.37035f
C1763 XRX.XFRONT.XFE_O.NIP.t21 VSS 0.36688f
C1764 XRX.XFRONT.XFE_O.NIP.n11 VSS 1.23967f
C1765 XRX.XFRONT.XFE_O.NIP.t22 VSS 0.36688f
C1766 XRX.XFRONT.XFE_O.NIP.t4 VSS 0.36688f
C1767 XRX.XFRONT.XFE_O.NIP.n12 VSS 1.22977f
C1768 XRX.XFRONT.XFE_O.NIP.n13 VSS 0.6459f
C1769 XRX.XFRONT.XFE_O.NIP.t5 VSS 0.36688f
C1770 XRX.XFRONT.XFE_O.NIP.t6 VSS 0.36688f
C1771 XRX.XFRONT.XFE_O.NIP.n14 VSS 1.22977f
C1772 XRX.XFRONT.XFE_O.NIP.t3 VSS 0.36688f
C1773 XRX.XFRONT.XFE_O.NIP.t23 VSS 0.37035f
C1774 XRX.XFRONT.XFE_O.NIP.n15 VSS 1.23967f
C1775 XRX.XFRONT.XFE_O.NIP.t1 VSS 0.36688f
C1776 XRX.XFRONT.XFE_O.NIP.t2 VSS 0.36688f
C1777 XRX.XFRONT.XFE_O.NIP.n16 VSS 1.22977f
C1778 XRX.XFRONT.XFE_O.NIP.n17 VSS 0.6459f
C1779 XRX.XFRONT.XFE_O.NIP.t7 VSS 0.36688f
C1780 XRX.XFRONT.XFE_O.NIP.t0 VSS 0.36688f
C1781 XRX.XFRONT.XFE_O.NIP.n18 VSS 1.22977f
C1782 XRX.XFRONT.XFE_O.NIP.n19 VSS 0.36463f
C1783 XRX.XFRONT.XFE_O.NIP.n20 VSS 0.93417f
C1784 XRX.XFRONT.XFE_O.NIP.n21 VSS 0.86596f
C1785 XRX.XFRONT.XFE_O.NIN.t4 VSS 0.37276f
C1786 XRX.XFRONT.XFE_O.NIN.t5 VSS 0.36932f
C1787 XRX.XFRONT.XFE_O.NIN.n0 VSS 1.25728f
C1788 XRX.XFRONT.XFE_O.NIN.t6 VSS 0.36932f
C1789 XRX.XFRONT.XFE_O.NIN.t7 VSS 0.36932f
C1790 XRX.XFRONT.XFE_O.NIN.n1 VSS 1.24724f
C1791 XRX.XFRONT.XFE_O.NIN.n2 VSS 0.65507f
C1792 XRX.XFRONT.XFE_O.NIN.t8 VSS 0.36932f
C1793 XRX.XFRONT.XFE_O.NIN.t9 VSS 0.36932f
C1794 XRX.XFRONT.XFE_O.NIN.n3 VSS 1.24724f
C1795 XRX.XFRONT.XFE_O.NIN.t2 VSS 0.36932f
C1796 XRX.XFRONT.XFE_O.NIN.t3 VSS 0.37276f
C1797 XRX.XFRONT.XFE_O.NIN.n4 VSS 1.25728f
C1798 XRX.XFRONT.XFE_O.NIN.t0 VSS 0.36932f
C1799 XRX.XFRONT.XFE_O.NIN.t1 VSS 0.36932f
C1800 XRX.XFRONT.XFE_O.NIN.n5 VSS 1.24724f
C1801 XRX.XFRONT.XFE_O.NIN.n6 VSS 0.65507f
C1802 XRX.XFRONT.XFE_O.NIN.t10 VSS 0.36932f
C1803 XRX.XFRONT.XFE_O.NIN.t11 VSS 0.36932f
C1804 XRX.XFRONT.XFE_O.NIN.n7 VSS 1.24724f
C1805 XRX.XFRONT.XFE_O.NIN.n8 VSS 0.36981f
C1806 XRX.XFRONT.XFE_O.NIN.n9 VSS 1.00904f
C1807 XRX.XFRONT.XFE_O.NIN.t15 VSS 1.6785f
C1808 XRX.XFRONT.XFE_O.NIN.t14 VSS 0.37271f
C1809 XRX.XFRONT.XFE_O.NIN.t13 VSS 0.37271f
C1810 XRX.XFRONT.XFE_O.NIN.n10 VSS 1.25651f
C1811 XRX.XFRONT.XFE_O.NIN.n11 VSS 0.61971f
C1812 XRX.XFRONT.XFE_O.NIN.t12 VSS 1.67426f
C1813 XRX.XFRONT.XFE_O.NIN.n12 VSS 3.4549f
C1814 XRX.XFRONT.XFE_O.NIN.n13 VSS 4.91382f
C1815 XRX.XFRONT.XFE_O.NIN.t23 VSS 1.60765f
C1816 XRX.XFRONT.XFE_O.NIN.t22 VSS 0.30322f
C1817 XRX.XFRONT.XFE_O.NIN.t21 VSS 0.30322f
C1818 XRX.XFRONT.XFE_O.NIN.n14 VSS 1.24724f
C1819 XRX.XFRONT.XFE_O.NIN.n15 VSS 0.70293f
C1820 XRX.XFRONT.XFE_O.NIN.t20 VSS 0.30322f
C1821 XRX.XFRONT.XFE_O.NIN.t19 VSS 0.30322f
C1822 XRX.XFRONT.XFE_O.NIN.n16 VSS 1.24724f
C1823 XRX.XFRONT.XFE_O.NIN.n17 VSS 0.29885f
C1824 XRX.XFRONT.XFE_O.NIN.t16 VSS 1.60764f
C1825 XRX.XFRONT.XFE_O.NIN.t18 VSS 0.30322f
C1826 XRX.XFRONT.XFE_O.NIN.t17 VSS 0.30322f
C1827 XRX.XFRONT.XFE_O.NIN.n18 VSS 1.24724f
C1828 XRX.XFRONT.XFE_O.NIN.n19 VSS 0.63197f
C1829 XRX.XFRONT.XFE_O.NIN.n20 VSS 0.98797f
C1830 XRX.XFRONT.XFE_O.NIN.n21 VSS 1.39363f
C1831 XRX.XFRONT.XFE_E.DN.t2 VSS 0.88596f
C1832 XRX.XFRONT.XFE_E.DN.t3 VSS 0.8912f
C1833 XRX.XFRONT.XFE_E.DN.n0 VSS 0.52546f
C1834 XRX.XFRONT.XFE_E.DN.n1 VSS 0.33878f
C1835 XRX.XFRONT.XFE_E.DN.n2 VSS 0.06346f
C1836 XRX.XFRONT.XFE_E.DN.n3 VSS 0.09808f
C1837 XRX.XFRONT.XFE_E.DN.n4 VSS 0.13746f
C1838 XRX.XFRONT.XFE_E.DN.n5 VSS 0.0636f
C1839 XRX.XFRONT.XFE_E.DN.n6 VSS 0.0636f
C1840 XRX.XFRONT.XFE_E.DN.n7 VSS 0.18512f
C1841 XRX.XFRONT.XFE_E.DN.n8 VSS 0.27157f
C1842 XRX.XFRONT.XFE_E.DN.n9 VSS 0.0915f
C1843 XRX.XFRONT.XFE_E.DN.n10 VSS 0.09808f
C1844 XRX.XFRONT.XFE_E.DN.n11 VSS 0.09808f
C1845 XRX.XFRONT.XFE_E.DN.n12 VSS 0.09808f
C1846 XRX.XFRONT.XFE_E.DN.n13 VSS 0.13746f
C1847 XRX.XFRONT.XFE_E.DN.n14 VSS 0.13746f
C1848 XRX.XFRONT.XFE_E.DN.n15 VSS 0.13732f
C1849 XRX.XFRONT.XFE_E.DN.n16 VSS 0.09808f
C1850 XRX.XFRONT.XFE_E.DN.n17 VSS 0.09808f
C1851 XRX.XFRONT.XFE_E.DN.n18 VSS 0.0894f
C1852 XRX.XFRONT.XFE_E.DN.n19 VSS 0.14833f
C1853 XRX.XFRONT.XFE_E.DN.n20 VSS 0.61121f
C1854 XRX.XFRONT.XFE_E.DN.t4 VSS 0.88923f
C1855 XRX.XFRONT.XFE_E.DN.t5 VSS 0.2868f
C1856 XRX.XFRONT.XFE_E.DN.t0 VSS 0.2868f
C1857 XRX.XFRONT.XFE_E.DN.n21 VSS 0.57969f
C1858 XRX.XFRONT.XFE_E.DN.n22 VSS 0.31864f
C1859 XRX.XFRONT.XFE_E.DN.t1 VSS 0.88738f
C1860 XRX.XFRONT.XFE_E.DN.n23 VSS 0.98658f
C1861 XRX.XFRONT.XFE_E.DN.n24 VSS 1.33585f
C1862 XRX.XFRONT.XFE_E.DP.n0 VSS 0.34607f
C1863 XRX.XFRONT.XFE_E.DP.n1 VSS 0.06467f
C1864 XRX.XFRONT.XFE_E.DP.n2 VSS 0.09996f
C1865 XRX.XFRONT.XFE_E.DP.n3 VSS 0.14009f
C1866 XRX.XFRONT.XFE_E.DP.n4 VSS 0.06482f
C1867 XRX.XFRONT.XFE_E.DP.n5 VSS 0.06482f
C1868 XRX.XFRONT.XFE_E.DP.n6 VSS 0.18866f
C1869 XRX.XFRONT.XFE_E.DP.n7 VSS 0.27676f
C1870 XRX.XFRONT.XFE_E.DP.n8 VSS 0.09325f
C1871 XRX.XFRONT.XFE_E.DP.n9 VSS 0.09996f
C1872 XRX.XFRONT.XFE_E.DP.n10 VSS 0.09996f
C1873 XRX.XFRONT.XFE_E.DP.n11 VSS 0.09996f
C1874 XRX.XFRONT.XFE_E.DP.n12 VSS 0.14009f
C1875 XRX.XFRONT.XFE_E.DP.n13 VSS 0.14009f
C1876 XRX.XFRONT.XFE_E.DP.n14 VSS 0.13994f
C1877 XRX.XFRONT.XFE_E.DP.n15 VSS 0.09996f
C1878 XRX.XFRONT.XFE_E.DP.n16 VSS 0.09996f
C1879 XRX.XFRONT.XFE_E.DP.n17 VSS 0.09111f
C1880 XRX.XFRONT.XFE_E.DP.n18 VSS 0.15109f
C1881 XRX.XFRONT.XFE_E.DP.n19 VSS 0.54741f
C1882 XRX.XFRONT.XFE_E.DP.t2 VSS 0.90102f
C1883 XRX.XFRONT.XFE_E.DP.t3 VSS 0.89965f
C1884 XRX.XFRONT.XFE_E.DP.n20 VSS 0.60387f
C1885 XRX.XFRONT.XFE_E.DP.t1 VSS 0.90157f
C1886 XRX.XFRONT.XFE_E.DP.t5 VSS 0.28762f
C1887 XRX.XFRONT.XFE_E.DP.t0 VSS 0.28762f
C1888 XRX.XFRONT.XFE_E.DP.n21 VSS 0.59078f
C1889 XRX.XFRONT.XFE_E.DP.n22 VSS 0.32473f
C1890 XRX.XFRONT.XFE_E.DP.t4 VSS 0.89959f
C1891 XRX.XFRONT.XFE_E.DP.n23 VSS 1.08581f
C1892 XRX.XFRONT.XFE_E.DP.n24 VSS 1.41978f
C1893 XRX.XFRONT.XFE_O.DP.t0 VSS 0.89965f
C1894 XRX.XFRONT.XFE_O.DP.t1 VSS 0.90102f
C1895 XRX.XFRONT.XFE_O.DP.n0 VSS 0.60387f
C1896 XRX.XFRONT.XFE_O.DP.t2 VSS 0.90157f
C1897 XRX.XFRONT.XFE_O.DP.t3 VSS 0.28762f
C1898 XRX.XFRONT.XFE_O.DP.t4 VSS 0.28762f
C1899 XRX.XFRONT.XFE_O.DP.n1 VSS 0.59078f
C1900 XRX.XFRONT.XFE_O.DP.n2 VSS 0.32473f
C1901 XRX.XFRONT.XFE_O.DP.t5 VSS 0.89959f
C1902 XRX.XFRONT.XFE_O.DP.n3 VSS 1.08581f
C1903 XRX.XFRONT.XFE_O.DP.n4 VSS 1.42483f
C1904 XRX.XFRONT.XFE_O.DP.n5 VSS 0.34607f
C1905 XRX.XFRONT.XFE_O.DP.n6 VSS 0.09111f
C1906 XRX.XFRONT.XFE_O.DP.n7 VSS 0.06482f
C1907 XRX.XFRONT.XFE_O.DP.n8 VSS 0.09996f
C1908 XRX.XFRONT.XFE_O.DP.n9 VSS 0.06482f
C1909 XRX.XFRONT.XFE_O.DP.n10 VSS 0.09996f
C1910 XRX.XFRONT.XFE_O.DP.n11 VSS 0.13994f
C1911 XRX.XFRONT.XFE_O.DP.n12 VSS 0.14009f
C1912 XRX.XFRONT.XFE_O.DP.n13 VSS 0.14009f
C1913 XRX.XFRONT.XFE_O.DP.n14 VSS 0.14009f
C1914 XRX.XFRONT.XFE_O.DP.n15 VSS 0.27676f
C1915 XRX.XFRONT.XFE_O.DP.n16 VSS 0.09325f
C1916 XRX.XFRONT.XFE_O.DP.n17 VSS 0.18866f
C1917 XRX.XFRONT.XFE_O.DP.n18 VSS 0.09996f
C1918 XRX.XFRONT.XFE_O.DP.n19 VSS 0.09996f
C1919 XRX.XFRONT.XFE_O.DP.n20 VSS 0.09996f
C1920 XRX.XFRONT.XFE_O.DP.n21 VSS 0.09996f
C1921 XRX.XFRONT.XFE_O.DP.n22 VSS 0.06467f
C1922 XRX.XFRONT.XFE_O.DP.n23 VSS 0.15109f
C1923 XRX.XFRONT.XFE_O.DP.n24 VSS 0.54719f
C1924 XRX.XFRONT.XFE_O.DP.n25 VSS 0.24004f
C1925 XRX.XFRONT.XFE_O.DN.n0 VSS 0.33878f
C1926 XRX.XFRONT.XFE_O.DN.n1 VSS 0.0894f
C1927 XRX.XFRONT.XFE_O.DN.n2 VSS 0.0636f
C1928 XRX.XFRONT.XFE_O.DN.n3 VSS 0.09808f
C1929 XRX.XFRONT.XFE_O.DN.n4 VSS 0.0636f
C1930 XRX.XFRONT.XFE_O.DN.n5 VSS 0.09808f
C1931 XRX.XFRONT.XFE_O.DN.n6 VSS 0.13732f
C1932 XRX.XFRONT.XFE_O.DN.n7 VSS 0.13746f
C1933 XRX.XFRONT.XFE_O.DN.n8 VSS 0.13746f
C1934 XRX.XFRONT.XFE_O.DN.n9 VSS 0.13746f
C1935 XRX.XFRONT.XFE_O.DN.n10 VSS 0.27157f
C1936 XRX.XFRONT.XFE_O.DN.n11 VSS 0.0915f
C1937 XRX.XFRONT.XFE_O.DN.n12 VSS 0.18512f
C1938 XRX.XFRONT.XFE_O.DN.n13 VSS 0.09808f
C1939 XRX.XFRONT.XFE_O.DN.n14 VSS 0.09808f
C1940 XRX.XFRONT.XFE_O.DN.n15 VSS 0.09808f
C1941 XRX.XFRONT.XFE_O.DN.n16 VSS 0.09808f
C1942 XRX.XFRONT.XFE_O.DN.n17 VSS 0.06346f
C1943 XRX.XFRONT.XFE_O.DN.n18 VSS 0.14833f
C1944 XRX.XFRONT.XFE_O.DN.n19 VSS 0.61121f
C1945 XRX.XFRONT.XFE_O.DN.t2 VSS 0.88923f
C1946 XRX.XFRONT.XFE_O.DN.t0 VSS 0.2868f
C1947 XRX.XFRONT.XFE_O.DN.t1 VSS 0.2868f
C1948 XRX.XFRONT.XFE_O.DN.n20 VSS 0.57969f
C1949 XRX.XFRONT.XFE_O.DN.n21 VSS 0.31864f
C1950 XRX.XFRONT.XFE_O.DN.t5 VSS 0.88738f
C1951 XRX.XFRONT.XFE_O.DN.n22 VSS 0.98658f
C1952 XRX.XFRONT.XFE_O.DN.n23 VSS 1.34081f
C1953 XRX.XFRONT.XFE_O.DN.t3 VSS 0.8912f
C1954 XRX.XFRONT.XFE_O.DN.t4 VSS 0.88596f
C1955 XRX.XFRONT.XFE_O.DN.n24 VSS 0.52459f
C1956 XRX.XFRONT.XFE_O.DN.n25 VSS 0.3408f
C1957 XRX.XFRONT.XFE_E.NTAIL.t4 VSS 0.17388f
C1958 XRX.XFRONT.XFE_E.NTAIL.t3 VSS 0.17244f
C1959 XRX.XFRONT.XFE_E.NTAIL.n0 VSS 0.61838f
C1960 XRX.XFRONT.XFE_E.NTAIL.t6 VSS 0.17244f
C1961 XRX.XFRONT.XFE_E.NTAIL.t5 VSS 0.17244f
C1962 XRX.XFRONT.XFE_E.NTAIL.n1 VSS 0.61345f
C1963 XRX.XFRONT.XFE_E.NTAIL.n2 VSS 0.32219f
C1964 XRX.XFRONT.XFE_E.NTAIL.t0 VSS 0.17244f
C1965 XRX.XFRONT.XFE_E.NTAIL.t1 VSS 0.17244f
C1966 XRX.XFRONT.XFE_E.NTAIL.n3 VSS 0.61345f
C1967 XRX.XFRONT.XFE_E.NTAIL.t2 VSS 0.17244f
C1968 XRX.XFRONT.XFE_E.NTAIL.t7 VSS 0.17388f
C1969 XRX.XFRONT.XFE_E.NTAIL.n4 VSS 0.61838f
C1970 XRX.XFRONT.XFE_E.NTAIL.n5 VSS 0.68153f
C1971 XRX.XFRONT.XFE_E.NTAIL.t44 VSS 1.01658f
C1972 XRX.XFRONT.XFE_E.NTAIL.t43 VSS 0.20539f
C1973 XRX.XFRONT.XFE_E.NTAIL.t42 VSS 0.20539f
C1974 XRX.XFRONT.XFE_E.NTAIL.n6 VSS 0.7709f
C1975 XRX.XFRONT.XFE_E.NTAIL.n7 VSS 0.36115f
C1976 XRX.XFRONT.XFE_E.NTAIL.t41 VSS 0.20539f
C1977 XRX.XFRONT.XFE_E.NTAIL.t40 VSS 0.20539f
C1978 XRX.XFRONT.XFE_E.NTAIL.n8 VSS 0.7709f
C1979 XRX.XFRONT.XFE_E.NTAIL.n9 VSS 0.18974f
C1980 XRX.XFRONT.XFE_E.NTAIL.t39 VSS 0.20539f
C1981 XRX.XFRONT.XFE_E.NTAIL.t38 VSS 0.20539f
C1982 XRX.XFRONT.XFE_E.NTAIL.n10 VSS 0.7709f
C1983 XRX.XFRONT.XFE_E.NTAIL.n11 VSS 0.18974f
C1984 XRX.XFRONT.XFE_E.NTAIL.t37 VSS 0.20539f
C1985 XRX.XFRONT.XFE_E.NTAIL.t36 VSS 0.20539f
C1986 XRX.XFRONT.XFE_E.NTAIL.n12 VSS 0.7709f
C1987 XRX.XFRONT.XFE_E.NTAIL.n13 VSS 0.18974f
C1988 XRX.XFRONT.XFE_E.NTAIL.t35 VSS 0.20539f
C1989 XRX.XFRONT.XFE_E.NTAIL.t34 VSS 0.20539f
C1990 XRX.XFRONT.XFE_E.NTAIL.n14 VSS 0.7709f
C1991 XRX.XFRONT.XFE_E.NTAIL.n15 VSS 0.15485f
C1992 XRX.XFRONT.XFE_E.NTAIL.t21 VSS 1.01658f
C1993 XRX.XFRONT.XFE_E.NTAIL.t23 VSS 0.20539f
C1994 XRX.XFRONT.XFE_E.NTAIL.t22 VSS 0.20539f
C1995 XRX.XFRONT.XFE_E.NTAIL.n16 VSS 0.7709f
C1996 XRX.XFRONT.XFE_E.NTAIL.n17 VSS 0.36115f
C1997 XRX.XFRONT.XFE_E.NTAIL.t25 VSS 0.20539f
C1998 XRX.XFRONT.XFE_E.NTAIL.t24 VSS 0.20539f
C1999 XRX.XFRONT.XFE_E.NTAIL.n18 VSS 0.7709f
C2000 XRX.XFRONT.XFE_E.NTAIL.n19 VSS 0.18974f
C2001 XRX.XFRONT.XFE_E.NTAIL.t27 VSS 0.20539f
C2002 XRX.XFRONT.XFE_E.NTAIL.t26 VSS 0.20539f
C2003 XRX.XFRONT.XFE_E.NTAIL.n20 VSS 0.7709f
C2004 XRX.XFRONT.XFE_E.NTAIL.n21 VSS 0.18974f
C2005 XRX.XFRONT.XFE_E.NTAIL.t29 VSS 0.20539f
C2006 XRX.XFRONT.XFE_E.NTAIL.t28 VSS 0.20539f
C2007 XRX.XFRONT.XFE_E.NTAIL.n22 VSS 0.7709f
C2008 XRX.XFRONT.XFE_E.NTAIL.n23 VSS 0.18974f
C2009 XRX.XFRONT.XFE_E.NTAIL.t31 VSS 0.20539f
C2010 XRX.XFRONT.XFE_E.NTAIL.t30 VSS 0.20539f
C2011 XRX.XFRONT.XFE_E.NTAIL.n24 VSS 0.7709f
C2012 XRX.XFRONT.XFE_E.NTAIL.n25 VSS 0.18974f
C2013 XRX.XFRONT.XFE_E.NTAIL.t33 VSS 0.20539f
C2014 XRX.XFRONT.XFE_E.NTAIL.t32 VSS 0.20539f
C2015 XRX.XFRONT.XFE_E.NTAIL.n26 VSS 0.7709f
C2016 XRX.XFRONT.XFE_E.NTAIL.n27 VSS 0.15485f
C2017 XRX.XFRONT.XFE_E.NTAIL.n28 VSS 0.27405f
C2018 XRX.XFRONT.XFE_E.NTAIL.t9 VSS 0.18145f
C2019 XRX.XFRONT.XFE_E.NTAIL.t13 VSS 0.17982f
C2020 XRX.XFRONT.XFE_E.NTAIL.n29 VSS 0.61838f
C2021 XRX.XFRONT.XFE_E.NTAIL.t12 VSS 0.17982f
C2022 XRX.XFRONT.XFE_E.NTAIL.t11 VSS 0.17982f
C2023 XRX.XFRONT.XFE_E.NTAIL.n30 VSS 0.61345f
C2024 XRX.XFRONT.XFE_E.NTAIL.n31 VSS 0.32219f
C2025 XRX.XFRONT.XFE_E.NTAIL.t10 VSS 0.17982f
C2026 XRX.XFRONT.XFE_E.NTAIL.t15 VSS 0.17982f
C2027 XRX.XFRONT.XFE_E.NTAIL.n32 VSS 0.61345f
C2028 XRX.XFRONT.XFE_E.NTAIL.t14 VSS 0.17982f
C2029 XRX.XFRONT.XFE_E.NTAIL.t8 VSS 0.18146f
C2030 XRX.XFRONT.XFE_E.NTAIL.n33 VSS 0.61838f
C2031 XRX.XFRONT.XFE_E.NTAIL.n34 VSS 0.68023f
C2032 XRX.XFRONT.XFE_E.NTAIL.n35 VSS 1.60812f
C2033 XRX.XFRONT.XFE_E.NTAIL.t20 VSS 1.11825f
C2034 XRX.XFRONT.XFE_E.NTAIL.t17 VSS 0.31008f
C2035 XRX.XFRONT.XFE_E.NTAIL.t16 VSS 0.31244f
C2036 XRX.XFRONT.XFE_E.NTAIL.n36 VSS 0.77602f
C2037 XRX.XFRONT.XFE_E.NTAIL.t19 VSS 0.31008f
C2038 XRX.XFRONT.XFE_E.NTAIL.t18 VSS 0.31008f
C2039 XRX.XFRONT.XFE_E.NTAIL.n37 VSS 0.7709f
C2040 XRX.XFRONT.XFE_E.NTAIL.n38 VSS 0.28537f
C2041 XRX.XFRONT.XFE_E.NTAIL.n39 VSS 0.25093f
C2042 XRX.XFRONT.XFE_E.NTAIL.n40 VSS 0.44253f
C2043 XRX.XFRONT.XFE_O.NTAIL.t44 VSS 1.01658f
C2044 XRX.XFRONT.XFE_O.NTAIL.t43 VSS 0.20539f
C2045 XRX.XFRONT.XFE_O.NTAIL.t42 VSS 0.20539f
C2046 XRX.XFRONT.XFE_O.NTAIL.n0 VSS 0.7709f
C2047 XRX.XFRONT.XFE_O.NTAIL.n1 VSS 0.36114f
C2048 XRX.XFRONT.XFE_O.NTAIL.t41 VSS 0.20539f
C2049 XRX.XFRONT.XFE_O.NTAIL.t40 VSS 0.20539f
C2050 XRX.XFRONT.XFE_O.NTAIL.n2 VSS 0.7709f
C2051 XRX.XFRONT.XFE_O.NTAIL.n3 VSS 0.18974f
C2052 XRX.XFRONT.XFE_O.NTAIL.t39 VSS 0.20539f
C2053 XRX.XFRONT.XFE_O.NTAIL.t38 VSS 0.20539f
C2054 XRX.XFRONT.XFE_O.NTAIL.n4 VSS 0.7709f
C2055 XRX.XFRONT.XFE_O.NTAIL.n5 VSS 0.18974f
C2056 XRX.XFRONT.XFE_O.NTAIL.t37 VSS 0.20539f
C2057 XRX.XFRONT.XFE_O.NTAIL.t36 VSS 0.20539f
C2058 XRX.XFRONT.XFE_O.NTAIL.n6 VSS 0.7709f
C2059 XRX.XFRONT.XFE_O.NTAIL.n7 VSS 0.18974f
C2060 XRX.XFRONT.XFE_O.NTAIL.t35 VSS 0.20539f
C2061 XRX.XFRONT.XFE_O.NTAIL.t34 VSS 0.20539f
C2062 XRX.XFRONT.XFE_O.NTAIL.n8 VSS 0.7709f
C2063 XRX.XFRONT.XFE_O.NTAIL.n9 VSS 0.18974f
C2064 XRX.XFRONT.XFE_O.NTAIL.t33 VSS 0.20539f
C2065 XRX.XFRONT.XFE_O.NTAIL.t32 VSS 0.20539f
C2066 XRX.XFRONT.XFE_O.NTAIL.n10 VSS 0.7709f
C2067 XRX.XFRONT.XFE_O.NTAIL.n11 VSS 0.15485f
C2068 XRX.XFRONT.XFE_O.NTAIL.t21 VSS 1.01658f
C2069 XRX.XFRONT.XFE_O.NTAIL.t23 VSS 0.20539f
C2070 XRX.XFRONT.XFE_O.NTAIL.t22 VSS 0.20539f
C2071 XRX.XFRONT.XFE_O.NTAIL.n12 VSS 0.7709f
C2072 XRX.XFRONT.XFE_O.NTAIL.n13 VSS 0.36114f
C2073 XRX.XFRONT.XFE_O.NTAIL.t25 VSS 0.20539f
C2074 XRX.XFRONT.XFE_O.NTAIL.t24 VSS 0.20539f
C2075 XRX.XFRONT.XFE_O.NTAIL.n14 VSS 0.7709f
C2076 XRX.XFRONT.XFE_O.NTAIL.n15 VSS 0.18974f
C2077 XRX.XFRONT.XFE_O.NTAIL.t27 VSS 0.20539f
C2078 XRX.XFRONT.XFE_O.NTAIL.t26 VSS 0.20539f
C2079 XRX.XFRONT.XFE_O.NTAIL.n16 VSS 0.7709f
C2080 XRX.XFRONT.XFE_O.NTAIL.n17 VSS 0.18974f
C2081 XRX.XFRONT.XFE_O.NTAIL.t29 VSS 0.20539f
C2082 XRX.XFRONT.XFE_O.NTAIL.t28 VSS 0.20539f
C2083 XRX.XFRONT.XFE_O.NTAIL.n18 VSS 0.7709f
C2084 XRX.XFRONT.XFE_O.NTAIL.n19 VSS 0.18974f
C2085 XRX.XFRONT.XFE_O.NTAIL.t31 VSS 0.20539f
C2086 XRX.XFRONT.XFE_O.NTAIL.t30 VSS 0.20539f
C2087 XRX.XFRONT.XFE_O.NTAIL.n20 VSS 0.7709f
C2088 XRX.XFRONT.XFE_O.NTAIL.n21 VSS 0.15485f
C2089 XRX.XFRONT.XFE_O.NTAIL.n22 VSS 0.27405f
C2090 XRX.XFRONT.XFE_O.NTAIL.t15 VSS 0.18151f
C2091 XRX.XFRONT.XFE_O.NTAIL.t14 VSS 0.17987f
C2092 XRX.XFRONT.XFE_O.NTAIL.n23 VSS 0.61838f
C2093 XRX.XFRONT.XFE_O.NTAIL.t13 VSS 0.17987f
C2094 XRX.XFRONT.XFE_O.NTAIL.t20 VSS 0.17987f
C2095 XRX.XFRONT.XFE_O.NTAIL.n24 VSS 0.61345f
C2096 XRX.XFRONT.XFE_O.NTAIL.t17 VSS 0.17987f
C2097 XRX.XFRONT.XFE_O.NTAIL.t16 VSS 0.1815f
C2098 XRX.XFRONT.XFE_O.NTAIL.n25 VSS 0.61838f
C2099 XRX.XFRONT.XFE_O.NTAIL.t19 VSS 0.17987f
C2100 XRX.XFRONT.XFE_O.NTAIL.t18 VSS 0.17987f
C2101 XRX.XFRONT.XFE_O.NTAIL.n26 VSS 0.61345f
C2102 XRX.XFRONT.XFE_O.NTAIL.n27 VSS 0.32219f
C2103 XRX.XFRONT.XFE_O.NTAIL.n28 VSS 0.68023f
C2104 XRX.XFRONT.XFE_O.NTAIL.n29 VSS 1.60812f
C2105 XRX.XFRONT.XFE_O.NTAIL.t4 VSS 0.31244f
C2106 XRX.XFRONT.XFE_O.NTAIL.t3 VSS 0.31008f
C2107 XRX.XFRONT.XFE_O.NTAIL.n30 VSS 0.77602f
C2108 XRX.XFRONT.XFE_O.NTAIL.t2 VSS 0.31008f
C2109 XRX.XFRONT.XFE_O.NTAIL.t1 VSS 0.31008f
C2110 XRX.XFRONT.XFE_O.NTAIL.n31 VSS 0.7709f
C2111 XRX.XFRONT.XFE_O.NTAIL.n32 VSS 0.28537f
C2112 XRX.XFRONT.XFE_O.NTAIL.t0 VSS 1.11825f
C2113 XRX.XFRONT.XFE_O.NTAIL.n33 VSS 0.25093f
C2114 XRX.XFRONT.XFE_O.NTAIL.n34 VSS 0.44781f
C2115 XRX.XFRONT.XFE_O.NTAIL.t8 VSS 0.17383f
C2116 XRX.XFRONT.XFE_O.NTAIL.t7 VSS 0.17239f
C2117 XRX.XFRONT.XFE_O.NTAIL.n35 VSS 0.61838f
C2118 XRX.XFRONT.XFE_O.NTAIL.t6 VSS 0.17239f
C2119 XRX.XFRONT.XFE_O.NTAIL.t5 VSS 0.17239f
C2120 XRX.XFRONT.XFE_O.NTAIL.n36 VSS 0.61345f
C2121 XRX.XFRONT.XFE_O.NTAIL.t10 VSS 0.17239f
C2122 XRX.XFRONT.XFE_O.NTAIL.t9 VSS 0.17383f
C2123 XRX.XFRONT.XFE_O.NTAIL.n37 VSS 0.61838f
C2124 XRX.XFRONT.XFE_O.NTAIL.t12 VSS 0.17239f
C2125 XRX.XFRONT.XFE_O.NTAIL.t11 VSS 0.17239f
C2126 XRX.XFRONT.XFE_O.NTAIL.n38 VSS 0.61345f
C2127 XRX.XFRONT.XFE_O.NTAIL.n39 VSS 0.32219f
C2128 XRX.XFRONT.XFE_O.NTAIL.n40 VSS 0.68023f
C2129 XRX.XFRONT.XFE_O.NTAIL.n41 VSS 0.4795f
C2130 a_948_44200.t0 VSS 0.62246f
C2131 a_948_44200.t3 VSS 0.1331f
C2132 a_948_44200.t2 VSS 0.1331f
C2133 a_948_44200.n0 VSS 0.51748f
C2134 a_948_44200.t5 VSS 0.13204f
C2135 a_948_44200.t4 VSS 0.13204f
C2136 a_948_44200.n1 VSS 0.47973f
C2137 a_948_44200.n2 VSS 3.66241f
C2138 a_948_44200.n3 VSS 0.50661f
C2139 a_948_44200.t1 VSS 0.62246f
C2140 a_2548_44200.t5 VSS 0.83067f
C2141 a_2548_44200.t1 VSS 0.17897f
C2142 a_2548_44200.t0 VSS 0.17897f
C2143 a_2548_44200.n0 VSS 0.62947f
C2144 a_2548_44200.t3 VSS 0.18689f
C2145 a_2548_44200.t2 VSS 0.18689f
C2146 a_2548_44200.n1 VSS 0.59103f
C2147 a_2548_44200.n2 VSS 2.81846f
C2148 a_2548_44200.n3 VSS 0.69295f
C2149 a_2548_44200.t4 VSS 0.83067f
C2150 a_10548_44200.t0 VSS 0.60188f
C2151 a_10548_44200.t3 VSS 0.13032f
C2152 a_10548_44200.t2 VSS 0.13032f
C2153 a_10548_44200.n0 VSS 0.50161f
C2154 a_10548_44200.t5 VSS 0.12927f
C2155 a_10548_44200.t4 VSS 0.12927f
C2156 a_10548_44200.n1 VSS 0.46501f
C2157 a_10548_44200.n2 VSS 3.55006f
C2158 a_10548_44200.n3 VSS 0.49107f
C2159 a_10548_44200.t1 VSS 0.60188f
C2160 a_12148_44200.t0 VSS 0.82401f
C2161 a_12148_44200.t5 VSS 0.18562f
C2162 a_12148_44200.t4 VSS 0.18562f
C2163 a_12148_44200.n0 VSS 0.62265f
C2164 a_12148_44200.t3 VSS 0.1776f
C2165 a_12148_44200.t2 VSS 0.1776f
C2166 a_12148_44200.n1 VSS 0.58462f
C2167 a_12148_44200.n2 VSS 2.78788f
C2168 a_12148_44200.n3 VSS 0.68544f
C2169 a_12148_44200.t1 VSS 0.82401f
C2170 a_2148_41600.t2 VSS 0.1448f
C2171 a_2148_41600.t1 VSS 0.1448f
C2172 a_2148_41600.n0 VSS 0.41454f
C2173 a_2148_41600.n1 VSS 0.13505f
C2174 a_2148_41600.t0 VSS 0.59158f
C2175 a_2148_41600.n2 VSS 0.12082f
C2176 a_2148_41600.t6 VSS 0.10946f
C2177 a_2148_41600.t7 VSS 0.10946f
C2178 a_2148_41600.n3 VSS 0.38577f
C2179 a_2148_41600.t5 VSS 0.1116f
C2180 a_2148_41600.t4 VSS 0.1116f
C2181 a_2148_41600.n4 VSS 0.38577f
C2182 a_2148_41600.n5 VSS 1.18313f
C2183 a_2148_41600.n6 VSS 0.35665f
C2184 a_2148_41600.n7 VSS 0.11907f
C2185 a_2148_41600.t3 VSS 0.59332f
C2186 a_11748_41600.t2 VSS 0.14207f
C2187 a_11748_41600.t1 VSS 0.14207f
C2188 a_11748_41600.n0 VSS 0.40451f
C2189 a_11748_41600.n1 VSS 0.13178f
C2190 a_11748_41600.t0 VSS 0.57804f
C2191 a_11748_41600.n2 VSS 0.1179f
C2192 a_11748_41600.t4 VSS 0.10941f
C2193 a_11748_41600.t5 VSS 0.10941f
C2194 a_11748_41600.n3 VSS 0.37643f
C2195 a_11748_41600.t6 VSS 0.10728f
C2196 a_11748_41600.t7 VSS 0.10728f
C2197 a_11748_41600.n4 VSS 0.37643f
C2198 a_11748_41600.n5 VSS 1.15448f
C2199 a_11748_41600.n6 VSS 0.34802f
C2200 a_11748_41600.n7 VSS 0.11619f
C2201 a_11748_41600.t3 VSS 0.57975f
C2202 a_65000_32348.t0 VSS 0.40381f
C2203 a_65000_32348.t2 VSS 0.1108f
C2204 a_65000_32348.n0 VSS 0.62359f
C2205 a_65000_32348.n1 VSS 1.90643f
C2206 a_65000_32348.n2 VSS 0.20818f
C2207 a_65000_32348.t1 VSS 0.40381f
C2208 a_66600_32348.t1 VSS 0.44843f
C2209 a_66600_32348.t0 VSS 0.12423f
C2210 a_66600_32348.n0 VSS 0.69915f
C2211 a_66600_32348.n1 VSS 2.1374f
C2212 a_66600_32348.n2 VSS 0.2334f
C2213 a_66600_32348.t2 VSS 0.44843f
C2214 a_65148_38800.t2 VSS 0.18579f
C2215 a_65148_38800.t1 VSS 0.18579f
C2216 a_65148_38800.n0 VSS 0.49537f
C2217 a_65148_38800.n1 VSS 0.14138f
C2218 a_65148_38800.t0 VSS 0.72279f
C2219 a_65148_38800.n2 VSS 0.12665f
C2220 a_65148_38800.t5 VSS 0.18727f
C2221 a_65148_38800.t4 VSS 0.18727f
C2222 a_65148_38800.n3 VSS 0.46086f
C2223 a_65148_38800.t7 VSS 0.17926f
C2224 a_65148_38800.t6 VSS 0.17926f
C2225 a_65148_38800.n4 VSS 0.46086f
C2226 a_65148_38800.n5 VSS 0.96523f
C2227 a_65148_38800.n6 VSS 0.42641f
C2228 a_65148_38800.n7 VSS 0.12487f
C2229 a_65148_38800.t3 VSS 0.72456f
C2230 a_n1000_22678.t1 VSS 0.43066f
C2231 a_n1000_22678.t0 VSS 0.11274f
C2232 a_n1000_22678.n0 VSS 0.61981f
C2233 a_n1000_22678.n1 VSS 1.98011f
C2234 a_n1000_22678.n2 VSS 0.20692f
C2235 a_n1000_22678.t2 VSS 0.43066f
C2236 a_600_22678.t0 VSS 0.47347f
C2237 a_600_22678.t2 VSS 0.12618f
C2238 a_600_22678.n0 VSS 0.69373f
C2239 a_600_22678.n1 VSS 2.21625f
C2240 a_600_22678.n2 VSS 0.23159f
C2241 a_600_22678.t1 VSS 0.47347f
C2242 a_n852_28800.t2 VSS 0.17014f
C2243 a_n852_28800.t1 VSS 0.17014f
C2244 a_n852_28800.n0 VSS 0.49564f
C2245 a_n852_28800.n1 VSS 0.14146f
C2246 a_n852_28800.t0 VSS 0.70725f
C2247 a_n852_28800.n2 VSS 0.12671f
C2248 a_n852_28800.t7 VSS 0.18675f
C2249 a_n852_28800.t4 VSS 0.18675f
C2250 a_n852_28800.n3 VSS 0.46111f
C2251 a_n852_28800.t6 VSS 0.17892f
C2252 a_n852_28800.t5 VSS 0.17892f
C2253 a_n852_28800.n4 VSS 0.46111f
C2254 a_n852_28800.n5 VSS 0.96575f
C2255 a_n852_28800.n6 VSS 0.42664f
C2256 a_n852_28800.n7 VSS 0.12494f
C2257 a_n852_28800.t3 VSS 0.70902f
C2258 a_65148_29400.t2 VSS 0.20009f
C2259 a_65148_29400.t1 VSS 0.20009f
C2260 a_65148_29400.n0 VSS 0.54754f
C2261 a_65148_29400.n1 VSS 0.15627f
C2262 a_65148_29400.t0 VSS 0.79359f
C2263 a_65148_29400.n2 VSS 0.13999f
C2264 a_65148_29400.t6 VSS 0.14123f
C2265 a_65148_29400.t7 VSS 0.14123f
C2266 a_65148_29400.n3 VSS 0.5094f
C2267 a_65148_29400.t4 VSS 0.14333f
C2268 a_65148_29400.t5 VSS 0.14333f
C2269 a_65148_29400.n4 VSS 0.5094f
C2270 a_65148_29400.n5 VSS 1.06689f
C2271 a_65148_29400.n6 VSS 0.47132f
C2272 a_65148_29400.n7 VSS 0.13803f
C2273 a_65148_29400.t3 VSS 0.79555f
C2274 a_72404_31500.t0 VSS 0.17833f
C2275 a_72404_31500.t4 VSS 0.09871f
C2276 a_72404_31500.n0 VSS 0.54876f
C2277 a_72404_31500.n1 VSS 1.66326f
C2278 a_72404_31500.t2 VSS 0.19463f
C2279 a_72404_31500.t3 VSS 0.19469f
C2280 a_72404_31500.n2 VSS 0.1374f
C2281 a_72404_31500.n3 VSS 0.52932f
C2282 a_72404_31500.n4 VSS 0.1374f
C2283 a_72404_31500.t1 VSS 0.17827f
C2284 a_75604_31500.t0 VSS 0.20322f
C2285 a_75604_31500.t4 VSS 0.10869f
C2286 a_75604_31500.n0 VSS 0.46491f
C2287 a_75604_31500.n1 VSS 1.75239f
C2288 a_75604_31500.t2 VSS 0.22573f
C2289 a_75604_31500.t3 VSS 0.22566f
C2290 a_75604_31500.n2 VSS 0.15993f
C2291 a_75604_31500.n3 VSS 0.66558f
C2292 a_75604_31500.n4 VSS 0.15993f
C2293 a_75604_31500.t1 VSS 0.20328f
C2294 a_72548_31500.t5 VSS 0.07418f
C2295 a_72548_31500.t7 VSS 0.30037f
C2296 a_72548_31500.n0 VSS 0.11128f
C2297 a_72548_31500.t3 VSS 0.08269f
C2298 a_72548_31500.t2 VSS 0.08269f
C2299 a_72548_31500.n1 VSS 0.33204f
C2300 a_72548_31500.t1 VSS 0.08274f
C2301 a_72548_31500.t0 VSS 0.08274f
C2302 a_72548_31500.n2 VSS 0.33204f
C2303 a_72548_31500.n3 VSS 2.92442f
C2304 a_72548_31500.n4 VSS 0.29793f
C2305 a_72548_31500.t4 VSS 0.2986f
C2306 a_72548_31500.n5 VSS 0.11305f
C2307 a_72548_31500.n6 VSS 0.12482f
C2308 a_72548_31500.n7 VSS 0.21494f
C2309 a_72548_31500.t6 VSS 0.07418f
C2310 a_74148_31500.t1 VSS 0.1035f
C2311 a_74148_31500.t0 VSS 0.1035f
C2312 a_74148_31500.n0 VSS 0.28247f
C2313 a_74148_31500.t6 VSS 0.09746f
C2314 a_74148_31500.t7 VSS 0.09746f
C2315 a_74148_31500.n1 VSS 0.29444f
C2316 a_74148_31500.n2 VSS 2.12933f
C2317 a_74148_31500.n3 VSS 0.52382f
C2318 a_74148_31500.t4 VSS 0.06565f
C2319 a_74148_31500.t3 VSS 0.06565f
C2320 a_74148_31500.n4 VSS 0.20875f
C2321 a_74148_31500.t2 VSS 0.28511f
C2322 a_74148_31500.n5 VSS 0.12149f
C2323 a_74148_31500.n6 VSS 0.12123f
C2324 a_74148_31500.n7 VSS 0.10672f
C2325 a_74148_31500.t5 VSS 0.28339f
C2326 a_80148_31500.t5 VSS 0.10488f
C2327 a_80148_31500.t7 VSS 0.4119f
C2328 a_80148_31500.n0 VSS 0.08148f
C2329 a_80148_31500.t1 VSS 0.07095f
C2330 a_80148_31500.t0 VSS 0.07095f
C2331 a_80148_31500.n1 VSS 0.17413f
C2332 a_80148_31500.t3 VSS 0.06639f
C2333 a_80148_31500.t2 VSS 0.06639f
C2334 a_80148_31500.n2 VSS 0.17413f
C2335 a_80148_31500.n3 VSS 0.75464f
C2336 a_80148_31500.n4 VSS 0.40413f
C2337 a_80148_31500.t4 VSS 0.4107f
C2338 a_80148_31500.n5 VSS 0.08268f
C2339 a_80148_31500.n6 VSS 0.09242f
C2340 a_80148_31500.n7 VSS 0.28368f
C2341 a_80148_31500.t6 VSS 0.10488f
C2342 a_n852_19400.t2 VSS 0.18447f
C2343 a_n852_19400.t1 VSS 0.18447f
C2344 a_n852_19400.n0 VSS 0.5479f
C2345 a_n852_19400.n1 VSS 0.15638f
C2346 a_n852_19400.t0 VSS 0.77818f
C2347 a_n852_19400.n2 VSS 0.14008f
C2348 a_n852_19400.t4 VSS 0.16971f
C2349 a_n852_19400.t5 VSS 0.16971f
C2350 a_n852_19400.n3 VSS 0.50974f
C2351 a_n852_19400.t6 VSS 0.17261f
C2352 a_n852_19400.t7 VSS 0.17261f
C2353 a_n852_19400.n4 VSS 0.50974f
C2354 a_n852_19400.n5 VSS 1.06759f
C2355 a_n852_19400.n6 VSS 0.47163f
C2356 a_n852_19400.n7 VSS 0.13812f
C2357 a_n852_19400.t3 VSS 0.78013f
C2358 a_n6716_3500.t1 VSS 0.543f
C2359 a_n6716_3500.t0 VSS 1.11245f
C2360 a_n6572_3500.t1 VSS 0.53009f
C2361 a_n6572_3500.t3 VSS 0.11763f
C2362 a_n6572_3500.t4 VSS 0.11768f
C2363 a_n6572_3500.n0 VSS 0.18549f
C2364 a_n6572_3500.t0 VSS 0.36985f
C2365 a_n6572_3500.t5 VSS 0.15622f
C2366 a_n6572_3500.n1 VSS 1.39633f
C2367 a_n6572_3500.n2 VSS 0.64607f
C2368 a_n6572_3500.n3 VSS 0.84861f
C2369 a_n6572_3500.n4 VSS 2.74162f
C2370 a_n6572_3500.n5 VSS 0.25248f
C2371 a_n6572_3500.t2 VSS 0.53018f
C2372 a_n3600_5641.t4 VSS 0.49714f
C2373 a_n3600_5641.t2 VSS 0.11508f
C2374 a_n3600_5641.t3 VSS 0.11503f
C2375 a_n3600_5641.n0 VSS 0.18273f
C2376 a_n3600_5641.t0 VSS 0.3653f
C2377 a_n3600_5641.t1 VSS 0.1539f
C2378 a_n3600_5641.n1 VSS 1.37555f
C2379 a_n3600_5641.n2 VSS 0.55474f
C2380 a_n3600_5641.n3 VSS 1.07214f
C2381 a_n3600_5641.n4 VSS 2.44613f
C2382 a_n3600_5641.n5 VSS 0.28121f
C2383 a_n3600_5641.t5 VSS 0.49705f
C2384 a_n1900_5958.t1 VSS 0.5683f
C2385 a_n1900_5958.t0 VSS 1.16128f
C2386 a_484_3500.t1 VSS 0.57067f
C2387 a_484_3500.t0 VSS 1.16586f
C2388 a_5300_5958.t1 VSS 0.53942f
C2389 a_5300_5958.t0 VSS 1.11788f
C2390 a_n5052_2600.t5 VSS 0.03011f
C2391 a_n5052_2600.t7 VSS 0.12119f
C2392 a_n5052_2600.t4 VSS 0.12119f
C2393 a_n5052_2600.t0 VSS 0.04306f
C2394 a_n5052_2600.t1 VSS 0.04303f
C2395 a_n5052_2600.n0 VSS 0.10737f
C2396 a_n5052_2600.t3 VSS 0.04419f
C2397 a_n5052_2600.t2 VSS 0.04422f
C2398 a_n5052_2600.n1 VSS 0.10737f
C2399 a_n5052_2600.n2 VSS 0.98516f
C2400 a_n5052_2600.n3 VSS 0.46257f
C2401 a_n5052_2600.n4 VSS 0.09122f
C2402 a_n5052_2600.t6 VSS 0.03011f
C2403 a_n5052_n1000.t8 VSS 0.15606f
C2404 a_n5052_n1000.t6 VSS 0.15561f
C2405 a_n5052_n1000.t5 VSS 0.15561f
C2406 a_n5052_n1000.n0 VSS 0.45893f
C2407 a_n5052_n1000.n1 VSS 0.14951f
C2408 a_n5052_n1000.t4 VSS 0.65016f
C2409 a_n5052_n1000.n2 VSS 0.13501f
C2410 a_n5052_n1000.t0 VSS 0.14185f
C2411 a_n5052_n1000.t1 VSS 0.14185f
C2412 a_n5052_n1000.n3 VSS 0.50742f
C2413 a_n5052_n1000.t2 VSS 0.16764f
C2414 a_n5052_n1000.t3 VSS 0.16764f
C2415 a_n5052_n1000.n4 VSS 0.50742f
C2416 a_n5052_n1000.n5 VSS 1.21852f
C2417 a_n5052_n1000.n6 VSS 0.49183f
C2418 a_n5052_n1000.n7 VSS 0.11815f
C2419 a_n5052_n1000.n8 VSS 0.4607f
C2420 a_n5052_n1000.t7 VSS 0.15561f
C2421 a_2148_n500.t6 VSS 0.10871f
C2422 a_2148_n500.t5 VSS 0.10871f
C2423 a_2148_n500.t4 VSS 0.10871f
C2424 a_2148_n500.n0 VSS 0.28658f
C2425 a_2148_n500.n1 VSS 0.09336f
C2426 a_2148_n500.t3 VSS 0.4177f
C2427 a_2148_n500.n2 VSS 0.08431f
C2428 a_2148_n500.t0 VSS 0.08272f
C2429 a_2148_n500.t2 VSS 0.08272f
C2430 a_2148_n500.n3 VSS 0.17591f
C2431 a_2148_n500.t1 VSS 0.08338f
C2432 a_2148_n500.t8 VSS 0.08338f
C2433 a_2148_n500.n4 VSS 0.17591f
C2434 a_2148_n500.n5 VSS 0.81634f
C2435 a_2148_n500.n6 VSS 0.37461f
C2436 a_2148_n500.n7 VSS 0.07378f
C2437 a_2148_n500.n8 VSS 0.28768f
C2438 a_2148_n500.t7 VSS 0.10916f
C2439 a_n10800_n12572.n0 VSS 0.74217f
C2440 a_n10800_n12572.t0 VSS 0.12063f
C2441 a_n10800_n12572.n1 VSS 1.77193f
C2442 a_n10800_n12572.t1 VSS 0.16741f
C2443 a_n7300_n12700.t0 VSS 1.02298f
C2444 a_n7300_n12700.t4 VSS 0.97775f
C2445 a_n7300_n12700.t3 VSS 0.97216f
C2446 a_n7300_n12700.n0 VSS 0.54148f
C2447 a_n7300_n12700.t2 VSS 0.1493f
C2448 a_n7300_n12700.n1 VSS 2.1793f
C2449 a_n7300_n12700.n2 VSS 0.35701f
C2450 a_n7300_n12700.t1 VSS 1.01737f
C2451 a_n6400_n12652.t1 VSS 0.31174f
C2452 a_n6400_n12652.t4 VSS 0.26683f
C2453 a_n6400_n12652.t3 VSS 0.26683f
C2454 a_n6400_n12652.n0 VSS 0.82091f
C2455 a_n6400_n12652.t2 VSS 0.16832f
C2456 a_n6400_n12652.n1 VSS 2.87005f
C2457 a_n6400_n12652.n2 VSS 0.94209f
C2458 a_n6400_n12652.t0 VSS 0.31174f
C2459 a_n10800_n14372.n0 VSS 0.8249f
C2460 a_n10800_n14372.t0 VSS 0.12987f
C2461 a_n10800_n14372.n1 VSS 1.96946f
C2462 a_n10800_n14372.t1 VSS 0.18155f
C2463 a_n7300_n14500.t0 VSS 1.05346f
C2464 a_n7300_n14500.t4 VSS 1.01146f
C2465 a_n7300_n14500.t3 VSS 1.0057f
C2466 a_n7300_n14500.n0 VSS 0.55746f
C2467 a_n7300_n14500.t2 VSS 0.15371f
C2468 a_n7300_n14500.n1 VSS 2.24362f
C2469 a_n7300_n14500.n2 VSS 0.36754f
C2470 a_n7300_n14500.t1 VSS 1.04768f
C2471 a_n6400_n14452.t1 VSS 0.31383f
C2472 a_n6400_n14452.t4 VSS 0.27216f
C2473 a_n6400_n14452.t3 VSS 0.27216f
C2474 a_n6400_n14452.n0 VSS 0.81591f
C2475 a_n6400_n14452.t2 VSS 0.16729f
C2476 a_n6400_n14452.n1 VSS 2.85257f
C2477 a_n6400_n14452.n2 VSS 0.93635f
C2478 a_n6400_n14452.t0 VSS 0.31383f
C2479 a_n10800_n16172.n0 VSS 0.8249f
C2480 a_n10800_n16172.t0 VSS 0.12987f
C2481 a_n10800_n16172.n1 VSS 1.96946f
C2482 a_n10800_n16172.t1 VSS 0.18155f
C2483 a_n7300_n16300.t0 VSS 1.05346f
C2484 a_n7300_n16300.t3 VSS 1.01146f
C2485 a_n7300_n16300.t4 VSS 1.0057f
C2486 a_n7300_n16300.n0 VSS 0.55746f
C2487 a_n7300_n16300.t2 VSS 0.15371f
C2488 a_n7300_n16300.n1 VSS 2.24362f
C2489 a_n7300_n16300.n2 VSS 0.36754f
C2490 a_n7300_n16300.t1 VSS 1.04768f
C2491 a_n6400_n16252.t2 VSS 0.31383f
C2492 a_n6400_n16252.t3 VSS 0.27216f
C2493 a_n6400_n16252.t4 VSS 0.27216f
C2494 a_n6400_n16252.n0 VSS 0.81591f
C2495 a_n6400_n16252.t0 VSS 0.16729f
C2496 a_n6400_n16252.n1 VSS 2.85257f
C2497 a_n6400_n16252.n2 VSS 0.93635f
C2498 a_n6400_n16252.t1 VSS 0.31383f
C2499 a_n10800_n17972.n0 VSS 0.8249f
C2500 a_n10800_n17972.t0 VSS 0.12987f
C2501 a_n10800_n17972.n1 VSS 1.96946f
C2502 a_n10800_n17972.t1 VSS 0.18155f
C2503 a_n7300_n18100.t2 VSS 1.01146f
C2504 a_n7300_n18100.t1 VSS 1.0057f
C2505 a_n7300_n18100.n0 VSS 0.55746f
C2506 a_n7300_n18100.t0 VSS 0.15371f
C2507 a_n7300_n18100.n1 VSS 2.24362f
C2508 a_n7300_n18100.t4 VSS 1.04768f
C2509 a_n7300_n18100.n2 VSS 0.36754f
C2510 a_n7300_n18100.t3 VSS 1.05346f
C2511 a_n6400_n18052.t2 VSS 0.27216f
C2512 a_n6400_n18052.t0 VSS 0.16729f
C2513 a_n6400_n18052.t3 VSS 0.31383f
C2514 a_n6400_n18052.t4 VSS 0.31383f
C2515 a_n6400_n18052.n0 VSS 0.93635f
C2516 a_n6400_n18052.n1 VSS 2.85257f
C2517 a_n6400_n18052.n2 VSS 0.81591f
C2518 a_n6400_n18052.t1 VSS 0.27216f
C2519 a_n10800_n19772.n0 VSS 0.8249f
C2520 a_n10800_n19772.t0 VSS 0.12987f
C2521 a_n10800_n19772.n1 VSS 1.96946f
C2522 a_n10800_n19772.t1 VSS 0.18155f
C2523 a_n7300_n19900.t2 VSS 1.05359f
C2524 a_n7300_n19900.t1 VSS 1.01158f
C2525 a_n7300_n19900.t4 VSS 1.00582f
C2526 a_n7300_n19900.n0 VSS 0.55754f
C2527 a_n7300_n19900.t0 VSS 0.15373f
C2528 a_n7300_n19900.n1 VSS 2.24392f
C2529 a_n7300_n19900.n2 VSS 0.36759f
C2530 a_n7300_n19900.t3 VSS 1.0478f
C2531 a_n6400_n19852.t4 VSS 0.27216f
C2532 a_n6400_n19852.t0 VSS 0.16729f
C2533 a_n6400_n19852.t2 VSS 0.31383f
C2534 a_n6400_n19852.t3 VSS 0.31383f
C2535 a_n6400_n19852.n0 VSS 0.93635f
C2536 a_n6400_n19852.n1 VSS 2.85257f
C2537 a_n6400_n19852.n2 VSS 0.81591f
C2538 a_n6400_n19852.t1 VSS 0.27216f
C2539 a_n10800_n21572.n0 VSS 0.82349f
C2540 a_n10800_n21572.t0 VSS 0.12929f
C2541 a_n10800_n21572.n1 VSS 1.96608f
C2542 a_n10800_n21572.t1 VSS 0.18086f
C2543 a_n7157_n21700.t1 VSS 1.05367f
C2544 a_n7157_n21700.t4 VSS 1.01242f
C2545 a_n7157_n21700.t3 VSS 1.00665f
C2546 a_n7157_n21700.n0 VSS 0.5581f
C2547 a_n7157_n21700.t0 VSS 0.15048f
C2548 a_n7157_n21700.n1 VSS 2.16743f
C2549 a_n7157_n21700.n2 VSS 0.36796f
C2550 a_n7157_n21700.t2 VSS 1.04788f
C2551 a_n6400_n21652.t1 VSS 0.31401f
C2552 a_n6400_n21652.t3 VSS 0.27309f
C2553 a_n6400_n21652.t2 VSS 0.27309f
C2554 a_n6400_n21652.n0 VSS 0.82003f
C2555 a_n6400_n21652.t4 VSS 0.16442f
C2556 a_n6400_n21652.n1 VSS 2.78096f
C2557 a_n6400_n21652.n2 VSS 0.94109f
C2558 a_n6400_n21652.t0 VSS 0.31401f
C2559 a_n10800_n23372.n0 VSS 0.78687f
C2560 a_n10800_n23372.t0 VSS 0.12249f
C2561 a_n10800_n23372.n1 VSS 1.87864f
C2562 a_n10800_n23372.t1 VSS 0.17169f
C2563 a_n7157_n23500.t1 VSS 0.98051f
C2564 a_n7157_n23500.t3 VSS 0.94316f
C2565 a_n7157_n23500.t0 VSS 0.9378f
C2566 a_n7157_n23500.n0 VSS 0.51899f
C2567 a_n7157_n23500.t4 VSS 0.13994f
C2568 a_n7157_n23500.n1 VSS 2.01556f
C2569 a_n7157_n23500.n2 VSS 0.34218f
C2570 a_n7157_n23500.t2 VSS 0.97513f
C2571 a_n6400_n23452.t4 VSS 0.26779f
C2572 a_n6400_n23452.t0 VSS 0.16253f
C2573 a_n6400_n23452.t3 VSS 0.30483f
C2574 a_n6400_n23452.t2 VSS 0.30483f
C2575 a_n6400_n23452.n0 VSS 0.93029f
C2576 a_n6400_n23452.n1 VSS 2.74905f
C2577 a_n6400_n23452.n2 VSS 0.81062f
C2578 a_n6400_n23452.t1 VSS 0.26779f
C2579 VSS.t599 VSS 0.13813f
C2580 VSS.t404 VSS 0.13813f
C2581 VSS.t488 VSS 0.14078f
C2582 VSS.t625 VSS 0.0866f
C2583 VSS.t626 VSS 0.08665f
C2584 VSS.t120 VSS 0.05334f
C2585 VSS.t118 VSS 0.05233f
C2586 VSS.t116 VSS 0.05233f
C2587 VSS.t114 VSS 0.05334f
C2588 VSS.t143 VSS 0.0497f
C2589 VSS.t141 VSS 0.04876f
C2590 VSS.t139 VSS 0.04876f
C2591 VSS.t137 VSS 0.0497f
C2592 VSS.t34 VSS 0.16234f
C2593 VSS.t36 VSS 0.16234f
C2594 VSS.t212 VSS 0.04063f
C2595 VSS.t210 VSS 0.03986f
C2596 VSS.t204 VSS 0.03986f
C2597 VSS.t202 VSS 0.04063f
C2598 VSS.t206 VSS 0.03986f
C2599 VSS.t205 VSS 0.03986f
C2600 VSS.t208 VSS 0.03986f
C2601 VSS.t207 VSS 0.03986f
C2602 VSS.t601 VSS 0.12931f
C2603 VSS.t597 VSS 0.13179f
C2604 VSS.t593 VSS 0.12931f
C2605 VSS.t241 VSS 0.16084f
C2606 VSS.t624 VSS 0.16084f
C2607 VSS.t223 VSS 0.03986f
C2608 VSS.t221 VSS 0.03986f
C2609 VSS.t215 VSS 0.03986f
C2610 VSS.t200 VSS 0.04063f
C2611 VSS.t216 VSS 0.03986f
C2612 VSS.t213 VSS 0.03986f
C2613 VSS.t219 VSS 0.03986f
C2614 VSS.t217 VSS 0.03986f
C2615 VSS.t253 VSS 0.08741f
C2616 VSS.t255 VSS 0.08746f
C2617 VSS.t605 VSS 0.08484f
C2618 VSS.t607 VSS 0.08489f
C2619 VSS.t491 VSS 0.16193f
C2620 VSS.t492 VSS 0.16193f
C2621 VSS.t603 VSS 0.12632f
C2622 VSS.t595 VSS 0.12632f
C2623 VSS.t490 VSS 0.12874f
C2624 VSS.t73 VSS 0.03807f
C2625 VSS.t61 VSS 0.03807f
C2626 VSS.t71 VSS 0.03807f
C2627 VSS.t69 VSS 0.03807f
C2628 VSS.t65 VSS 0.03807f
C2629 VSS.t50 VSS 0.0388f
C2630 VSS.t63 VSS 0.03807f
C2631 VSS.t67 VSS 0.03807f
C2632 VSS.t395 VSS 0.15757f
C2633 VSS.t396 VSS 0.15757f
C2634 VSS.t46 VSS 0.0388f
C2635 VSS.t59 VSS 0.03807f
C2636 VSS.t52 VSS 0.03807f
C2637 VSS.t44 VSS 0.0388f
C2638 VSS.t48 VSS 0.03807f
C2639 VSS.t54 VSS 0.03807f
C2640 VSS.t57 VSS 0.03807f
C2641 VSS.t56 VSS 0.03807f
C2642 VSS.t152 VSS 0.05471f
C2643 VSS.t148 VSS 0.05368f
C2644 VSS.t150 VSS 0.05368f
C2645 VSS.t146 VSS 0.05471f
C2646 VSS.t493 VSS 0.08719f
C2647 VSS.t365 VSS 0.08724f
C2648 VSS.t418 VSS 0.0567f
C2649 VSS.t420 VSS 0.05564f
C2650 VSS.t421 VSS 0.05564f
C2651 VSS.t416 VSS 0.0567f
C2652 VSS.t609 VSS 0.13279f
C2653 VSS.t482 VSS 0.13279f
C2654 VSS.t462 VSS 0.13533f
C2655 VSS.t349 VSS 0.05093f
C2656 VSS.t42 VSS 0.05439f
C2657 VSS.t380 VSS 0.05484f
C2658 VSS.t535 VSS 0.05484f
C2659 VSS.t107 VSS 0.05484f
C2660 VSS.t104 VSS 0.05484f
C2661 VSS.t112 VSS 0.05312f
C2662 VSS.t95 VSS 0.03465f
C2663 VSS.t93 VSS 0.03424f
C2664 VSS.t91 VSS 0.03424f
C2665 VSS.t89 VSS 0.03465f
C2666 VSS.t25 VSS 0.03199f
C2667 VSS.t23 VSS 0.03245f
C2668 VSS.t27 VSS 0.03245f
C2669 VSS.t17 VSS 0.03199f
C2670 VSS.t513 VSS 0.01731f
C2671 VSS.t512 VSS 0.0179f
C2672 VSS.t515 VSS 0.0179f
C2673 VSS.t514 VSS 0.01731f
C2674 VSS.t611 VSS 0.02768f
C2675 VSS.t613 VSS 0.02808f
C2676 VSS.t617 VSS 0.02808f
C2677 VSS.t615 VSS 0.02768f
C2678 VSS.t230 VSS 0.01042f
C2679 VSS.t228 VSS 0.01078f
C2680 VSS.t234 VSS 0.01078f
C2681 VSS.t232 VSS 0.01042f
C2682 VSS.t296 VSS 0.05055f
C2683 VSS.t295 VSS 0.04996f
C2684 VSS.t294 VSS 0.04996f
C2685 VSS.t291 VSS 0.05055f
C2686 VSS.t293 VSS 0.05055f
C2687 VSS.t290 VSS 0.04996f
C2688 VSS.t286 VSS 0.04996f
C2689 VSS.t288 VSS 0.05055f
C2690 VSS.t470 VSS 0.07134f
C2691 VSS.t468 VSS 0.06945f
C2692 VSS.t267 VSS 0.06945f
C2693 VSS.t269 VSS 0.07134f
C2694 VSS.t464 VSS 0.06945f
C2695 VSS.t357 VSS 0.06945f
C2696 VSS.t265 VSS 0.06945f
C2697 VSS.t263 VSS 0.06945f
C2698 VSS.t581 VSS 0.05734f
C2699 VSS.t579 VSS 0.05615f
C2700 VSS.t577 VSS 0.05615f
C2701 VSS.t573 VSS 0.05615f
C2702 VSS.t575 VSS 0.05615f
C2703 VSS.t571 VSS 0.05615f
C2704 VSS.t569 VSS 0.05615f
C2705 VSS.t568 VSS 0.05615f
C2706 VSS.t458 VSS 0.17816f
C2707 VSS.t460 VSS 0.17813f
C2708 VSS.t373 VSS 0.1632f
C2709 VSS.t369 VSS 0.16084f
C2710 VSS.t367 VSS 0.16084f
C2711 VSS.t375 VSS 0.16084f
C2712 VSS.t371 VSS 0.16084f
C2713 VSS.t249 VSS 0.17678f
C2714 VSS.t251 VSS 0.17682f
C2715 VSS.t591 VSS 0.11864f
C2716 VSS.t236 VSS 0.11641f
C2717 VSS.t238 VSS 0.11641f
C2718 VSS.t240 VSS 0.11641f
C2719 VSS.t466 VSS 0.07078f
C2720 VSS.t440 VSS 0.07271f
C2721 VSS.t179 VSS 0.07078f
C2722 VSS.t359 VSS 0.07078f
C2723 VSS.t394 VSS 0.07078f
C2724 VSS.t398 VSS 0.07078f
C2725 VSS.t181 VSS 0.0727f
C2726 VSS.t472 VSS 0.07078f
C2727 VSS.t432 VSS 0.15863f
C2728 VSS.t545 VSS 0.05615f
C2729 VSS.t543 VSS 0.05734f
C2730 VSS.t547 VSS 0.05615f
C2731 VSS.t541 VSS 0.05615f
C2732 VSS.t539 VSS 0.05615f
C2733 VSS.t549 VSS 0.05615f
C2734 VSS.t551 VSS 0.05615f
C2735 VSS.t537 VSS 0.05615f
C2736 VSS.t555 VSS 0.05615f
C2737 VSS.t553 VSS 0.05615f
C2738 VSS.t561 VSS 0.05615f
C2739 VSS.t557 VSS 0.05615f
C2740 VSS.t559 VSS 0.05615f
C2741 VSS.t563 VSS 0.05615f
C2742 VSS.t567 VSS 0.05615f
C2743 VSS.t565 VSS 0.05615f
C2744 VSS.t589 VSS 0.14369f
C2745 VSS.t447 VSS 0.12568f
C2746 VSS.t449 VSS 0.12332f
C2747 VSS.t428 VSS 0.12332f
C2748 VSS.t430 VSS 0.12332f
C2749 VSS.t19 VSS 0.03199f
C2750 VSS.t13 VSS 0.03245f
C2751 VSS.t15 VSS 0.03245f
C2752 VSS.t21 VSS 0.03199f
C2753 VSS.t99 VSS 0.03465f
C2754 VSS.t98 VSS 0.03424f
C2755 VSS.t97 VSS 0.03424f
C2756 VSS.t96 VSS 0.03465f
C2757 VSS.t519 VSS 0.03072f
C2758 VSS.t530 VSS 0.03072f
C2759 VSS.t531 VSS 0.03117f
C2760 VSS.t529 VSS 0.03072f
C2761 VSS.t521 VSS 0.03117f
C2762 VSS.t522 VSS 0.03117f
C2763 VSS.t534 VSS 0.03072f
C2764 VSS.t533 VSS 0.03072f
C2765 VSS.t518 VSS 0.03072f
C2766 VSS.t532 VSS 0.03117f
C2767 VSS.t344 VSS 0.05734f
C2768 VSS.t298 VSS 0.05615f
C2769 VSS.t342 VSS 0.05615f
C2770 VSS.t340 VSS 0.05615f
C2771 VSS.t322 VSS 0.05615f
C2772 VSS.t338 VSS 0.05615f
C2773 VSS.t336 VSS 0.05615f
C2774 VSS.t330 VSS 0.05615f
C2775 VSS.t334 VSS 0.05615f
C2776 VSS.t332 VSS 0.05615f
C2777 VSS.t324 VSS 0.05615f
C2778 VSS.t328 VSS 0.05615f
C2779 VSS.t326 VSS 0.05615f
C2780 VSS.t320 VSS 0.05615f
C2781 VSS.t170 VSS 0.17682f
C2782 VSS.t172 VSS 0.17678f
C2783 VSS.t194 VSS 0.11641f
C2784 VSS.t196 VSS 0.11641f
C2785 VSS.t198 VSS 0.11641f
C2786 VSS.t183 VSS 0.11864f
C2787 VSS.t391 VSS 0.07271f
C2788 VSS.t192 VSS 0.07078f
C2789 VSS.t474 VSS 0.07078f
C2790 VSS.t476 VSS 0.07078f
C2791 VSS.t478 VSS 0.07078f
C2792 VSS.t587 VSS 0.07078f
C2793 VSS.t585 VSS 0.07078f
C2794 VSS.t455 VSS 0.0727f
C2795 VSS.t434 VSS 0.15863f
C2796 VSS.t283 VSS 0.16084f
C2797 VSS.t281 VSS 0.16084f
C2798 VSS.t279 VSS 0.16084f
C2799 VSS.t277 VSS 0.16084f
C2800 VSS.t275 VSS 0.1632f
C2801 VSS.t582 VSS 0.17813f
C2802 VSS.t583 VSS 0.17816f
C2803 VSS.t318 VSS 0.05615f
C2804 VSS.t316 VSS 0.05615f
C2805 VSS.t308 VSS 0.05615f
C2806 VSS.t306 VSS 0.05734f
C2807 VSS.t310 VSS 0.05615f
C2808 VSS.t302 VSS 0.05615f
C2809 VSS.t304 VSS 0.05615f
C2810 VSS.t312 VSS 0.05615f
C2811 VSS.t314 VSS 0.05615f
C2812 VSS.t300 VSS 0.05615f
C2813 VSS.t185 VSS 0.14369f
C2814 VSS.t480 VSS 0.07134f
C2815 VSS.t445 VSS 0.06945f
C2816 VSS.t260 VSS 0.06945f
C2817 VSS.t257 VSS 0.06945f
C2818 VSS.t402 VSS 0.06945f
C2819 VSS.t400 VSS 0.06945f
C2820 VSS.t453 VSS 0.06945f
C2821 VSS.t426 VSS 0.07134f
C2822 VSS.t436 VSS 0.12332f
C2823 VSS.t438 VSS 0.12332f
C2824 VSS.t361 VSS 0.12332f
C2825 VSS.t363 VSS 0.12568f
C2826 VDD.t249 VSS 0.65694f
C2827 VDD.t248 VSS 0.59124f
C2828 VDD.t12 VSS 0.59124f
C2829 VDD.t11 VSS 0.59124f
C2830 VDD.t337 VSS 0.59124f
C2831 VDD.t336 VSS 0.59124f
C2832 VDD.t435 VSS 0.59124f
C2833 VDD.t434 VSS 0.59124f
C2834 VDD.t20 VSS 0.59124f
C2835 VDD.t19 VSS 0.59124f
C2836 VDD.t16 VSS 0.59124f
C2837 VDD.t15 VSS 0.59124f
C2838 VDD.t30 VSS 0.59124f
C2839 VDD.t29 VSS 0.33224f
C2840 VDD.t28 VSS 0.07833f
C2841 VDD.t14 VSS 0.08017f
C2842 VDD.n0 VSS 0.07432f
C2843 VDD.t27 VSS 0.43368f
C2844 VDD.t17 VSS 0.30024f
C2845 VDD.t18 VSS 0.08017f
C2846 VDD.t433 VSS 0.08017f
C2847 VDD.n1 VSS 0.07432f
C2848 VDD.t334 VSS 0.30024f
C2849 VDD.t335 VSS 0.08017f
C2850 VDD.t10 VSS 0.07969f
C2851 VDD.n2 VSS 0.07432f
C2852 VDD.t246 VSS 0.31107f
C2853 VDD.t247 VSS 0.07597f
C2854 VDD.n3 VSS 0.32191f
C2855 VDD.n4 VSS 0.05132f
C2856 VDD.n5 VSS 0.30781f
C2857 VDD.t9 VSS 0.30024f
C2858 VDD.n6 VSS 0.30781f
C2859 VDD.n7 VSS 0.05132f
C2860 VDD.n8 VSS 0.07432f
C2861 VDD.n9 VSS 0.05132f
C2862 VDD.n10 VSS 0.30781f
C2863 VDD.t432 VSS 0.30024f
C2864 VDD.n11 VSS 0.30781f
C2865 VDD.n12 VSS 0.05132f
C2866 VDD.n13 VSS 0.07432f
C2867 VDD.n14 VSS 0.05132f
C2868 VDD.n15 VSS 0.30781f
C2869 VDD.t13 VSS 0.30024f
C2870 VDD.n16 VSS 0.30781f
C2871 VDD.n17 VSS 0.05132f
C2872 VDD.n18 VSS 0.18021f
C2873 VDD.n19 VSS 1.22535f
C2874 VDD.n20 VSS 18.0077f
C2875 VDD.t431 VSS 0.05285f
C2876 VDD.t55 VSS 0.04641f
C2877 VDD.n21 VSS 0.28875f
C2878 VDD.t147 VSS 0.048f
C2879 VDD.t148 VSS 0.04578f
C2880 VDD.n22 VSS 0.24908f
C2881 VDD.n23 VSS 1.01938f
C2882 VDD.t479 VSS 0.03499f
C2883 VDD.t96 VSS 0.03312f
C2884 VDD.n24 VSS 0.41504f
C2885 VDD.t54 VSS 0.03499f
C2886 VDD.t256 VSS 0.03312f
C2887 VDD.n25 VSS 0.19672f
C2888 VDD.n26 VSS 0.32165f
C2889 VDD.n27 VSS 0.6477f
C2890 VDD.t53 VSS 0.04723f
C2891 VDD.t478 VSS 0.04027f
C2892 VDD.n28 VSS 0.46537f
C2893 VDD.t245 VSS 0.04027f
C2894 VDD.n29 VSS 0.50354f
C2895 VDD.t173 VSS 0.04027f
C2896 VDD.n30 VSS 0.59824f
C2897 VDD.t5 VSS 1.30874f
C2898 VDD.t6 VSS 1.57049f
C2899 VDD.t7 VSS 1.57049f
C2900 VDD.t8 VSS 1.20238f
C2901 VDD.t56 VSS 0.02845f
C2902 VDD.t338 VSS 0.03136f
C2903 VDD.n31 VSS 0.18839f
C2904 VDD.t132 VSS 0.03136f
C2905 VDD.n32 VSS 0.09614f
C2906 VDD.t238 VSS 0.02713f
C2907 VDD.n33 VSS 0.12171f
C2908 VDD.t48 VSS 0.02713f
C2909 VDD.n34 VSS 0.20708f
C2910 VDD.t79 VSS 0.03361f
C2911 VDD.n35 VSS 0.18127f
C2912 VDD.t47 VSS 0.03361f
C2913 VDD.n36 VSS 0.18127f
C2914 VDD.t131 VSS 0.02713f
C2915 VDD.n37 VSS 0.14274f
C2916 VDD.n38 VSS 2.70814f
C2917 VDD.t333 VSS 0.04164f
C2918 VDD.t60 VSS 0.03964f
C2919 VDD.n39 VSS 0.43005f
C2920 VDD.t170 VSS 0.04164f
C2921 VDD.t146 VSS 0.03964f
C2922 VDD.n40 VSS 0.21309f
C2923 VDD.n41 VSS 1.28697f
C2924 VDD.n42 VSS 7.39208f
C2925 VDD.n43 VSS 5.55324f
C2926 VDD.t390 VSS 0.13399f
C2927 VDD.t392 VSS 0.13636f
C2928 VDD.n44 VSS 0.05569f
C2929 VDD.t372 VSS 0.19092f
C2930 VDD.n45 VSS 0.15404f
C2931 VDD.n46 VSS 0.33111f
C2932 VDD.n47 VSS 0.4927f
C2933 VDD.t316 VSS 0.1055f
C2934 VDD.t314 VSS 0.10808f
C2935 VDD.n48 VSS 0.05569f
C2936 VDD.t320 VSS 0.1055f
C2937 VDD.t318 VSS 0.1055f
C2938 VDD.n49 VSS 0.05526f
C2939 VDD.n50 VSS 0.028f
C2940 VDD.t324 VSS 0.1055f
C2941 VDD.t322 VSS 0.1055f
C2942 VDD.n51 VSS 0.05526f
C2943 VDD.n52 VSS 0.01586f
C2944 VDD.t328 VSS 0.1055f
C2945 VDD.t326 VSS 0.1055f
C2946 VDD.n53 VSS 0.05526f
C2947 VDD.n54 VSS 0.01586f
C2948 VDD.t332 VSS 0.1055f
C2949 VDD.t330 VSS 0.1055f
C2950 VDD.n55 VSS 0.05526f
C2951 VDD.n56 VSS 0.22729f
C2952 VDD.n57 VSS 0.17084f
C2953 VDD.n58 VSS 0.4927f
C2954 VDD.t400 VSS 0.18884f
C2955 VDD.t102 VSS 0.18549f
C2956 VDD.n59 VSS 0.05548f
C2957 VDD.t104 VSS 0.18549f
C2958 VDD.t106 VSS 0.18549f
C2959 VDD.n60 VSS 0.05537f
C2960 VDD.n61 VSS 0.14749f
C2961 VDD.n62 VSS 0.20071f
C2962 VDD.t242 VSS 0.18749f
C2963 VDD.t244 VSS 0.18746f
C2964 VDD.n63 VSS 0.122f
C2965 VDD.n64 VSS 0.16565f
C2966 VDD.n65 VSS 0.4927f
C2967 VDD.t280 VSS 0.1055f
C2968 VDD.t278 VSS 0.1055f
C2969 VDD.n66 VSS 0.05569f
C2970 VDD.t288 VSS 0.1055f
C2971 VDD.t286 VSS 0.1055f
C2972 VDD.n67 VSS 0.05526f
C2973 VDD.n68 VSS 0.028f
C2974 VDD.t284 VSS 0.1055f
C2975 VDD.t290 VSS 0.1055f
C2976 VDD.n69 VSS 0.05526f
C2977 VDD.n70 VSS 0.01586f
C2978 VDD.t276 VSS 0.1055f
C2979 VDD.t292 VSS 0.1055f
C2980 VDD.n71 VSS 0.05526f
C2981 VDD.n72 VSS 0.01586f
C2982 VDD.t282 VSS 0.10808f
C2983 VDD.t294 VSS 0.1055f
C2984 VDD.n73 VSS 0.05526f
C2985 VDD.n74 VSS 0.21553f
C2986 VDD.n75 VSS 0.15565f
C2987 VDD.n76 VSS 0.4927f
C2988 VDD.t172 VSS 0.18416f
C2989 VDD.t487 VSS 0.18416f
C2990 VDD.n77 VSS 0.05526f
C2991 VDD.t489 VSS 0.18416f
C2992 VDD.t491 VSS 0.18749f
C2993 VDD.n78 VSS 0.05569f
C2994 VDD.n79 VSS 0.1474f
C2995 VDD.n80 VSS 0.21973f
C2996 VDD.t150 VSS 0.12708f
C2997 VDD.t152 VSS 0.12932f
C2998 VDD.n81 VSS 0.05569f
C2999 VDD.t471 VSS 0.18401f
C3000 VDD.n82 VSS 0.15404f
C3001 VDD.n83 VSS 0.34449f
C3002 VDD.n84 VSS 0.18209f
C3003 VDD.n85 VSS 0.0846f
C3004 VDD.n86 VSS 0.09658f
C3005 VDD.n87 VSS 0.09238f
C3006 VDD.t151 VSS 0.61588f
C3007 VDD.n88 VSS 0.09238f
C3008 VDD.n89 VSS 0.09658f
C3009 VDD.n90 VSS 0.09846f
C3010 VDD.n91 VSS 0.09658f
C3011 VDD.n92 VSS 0.09238f
C3012 VDD.t345 VSS 1.72446f
C3013 VDD.n93 VSS 0.26107f
C3014 VDD.t377 VSS 0.4927f
C3015 VDD.n94 VSS 0.09238f
C3016 VDD.n95 VSS 0.09658f
C3017 VDD.n96 VSS 0.09846f
C3018 VDD.n97 VSS 0.09658f
C3019 VDD.n98 VSS 0.09238f
C3020 VDD.t241 VSS 0.61588f
C3021 VDD.n99 VSS 0.09238f
C3022 VDD.n100 VSS 0.09658f
C3023 VDD.n101 VSS 0.09846f
C3024 VDD.n102 VSS 0.09658f
C3025 VDD.n103 VSS 0.09238f
C3026 VDD.t313 VSS 0.86223f
C3027 VDD.n104 VSS 0.41928f
C3028 VDD.n105 VSS 5.4668f
C3029 VDD.n106 VSS 0.09238f
C3030 VDD.n107 VSS 0.09658f
C3031 VDD.n108 VSS 0.08265f
C3032 VDD.n109 VSS 0.09658f
C3033 VDD.n110 VSS 0.09238f
C3034 VDD.n111 VSS 4.71473f
C3035 VDD.n112 VSS 3.55385f
C3036 VDD.n113 VSS 4.31114f
C3037 VDD.t391 VSS 2.46351f
C3038 VDD.t389 VSS 0.4927f
C3039 VDD.t371 VSS 0.61588f
C3040 VDD.n114 VSS 3.44891f
C3041 VDD.n115 VSS 0.09238f
C3042 VDD.n116 VSS 0.09658f
C3043 VDD.n117 VSS 0.26654f
C3044 VDD.n118 VSS 0.09846f
C3045 VDD.n119 VSS 0.09846f
C3046 VDD.n120 VSS 0.09658f
C3047 VDD.n121 VSS 0.09238f
C3048 VDD.n122 VSS 4.55749f
C3049 VDD.t168 VSS 1.72446f
C3050 VDD.t464 VSS 0.4927f
C3051 VDD.t466 VSS 0.4927f
C3052 VDD.t468 VSS 1.10858f
C3053 VDD.n123 VSS 0.9854f
C3054 VDD.t331 VSS 0.36953f
C3055 VDD.t329 VSS 0.4927f
C3056 VDD.t327 VSS 0.4927f
C3057 VDD.t325 VSS 0.4927f
C3058 VDD.t323 VSS 0.36953f
C3059 VDD.t105 VSS 0.24635f
C3060 VDD.t315 VSS 0.24635f
C3061 VDD.t103 VSS 0.24635f
C3062 VDD.t317 VSS 0.24635f
C3063 VDD.t101 VSS 0.24635f
C3064 VDD.t319 VSS 0.24635f
C3065 VDD.t399 VSS 0.24635f
C3066 VDD.t321 VSS 0.24635f
C3067 VDD.n124 VSS 0.4166f
C3068 VDD.n125 VSS 0.26107f
C3069 VDD.n126 VSS 0.26107f
C3070 VDD.n127 VSS 2.14106f
C3071 VDD.t307 VSS 1.72446f
C3072 VDD.t309 VSS 0.4927f
C3073 VDD.t305 VSS 0.4927f
C3074 VDD.t311 VSS 0.4927f
C3075 VDD.n128 VSS 2.34033f
C3076 VDD.t239 VSS 2.34033f
C3077 VDD.t484 VSS 0.4927f
C3078 VDD.t482 VSS 0.4927f
C3079 VDD.t480 VSS 0.4927f
C3080 VDD.n129 VSS 0.9854f
C3081 VDD.n130 VSS 0.09238f
C3082 VDD.n131 VSS 0.09658f
C3083 VDD.n132 VSS 0.09846f
C3084 VDD.n133 VSS 0.09846f
C3085 VDD.n134 VSS 0.09846f
C3086 VDD.n135 VSS 0.09658f
C3087 VDD.n136 VSS 0.09238f
C3088 VDD.n137 VSS 0.24635f
C3089 VDD.t243 VSS 2.21716f
C3090 VDD.t304 VSS 2.34033f
C3091 VDD.t303 VSS 0.4927f
C3092 VDD.t302 VSS 0.4927f
C3093 VDD.t301 VSS 0.36953f
C3094 VDD.n138 VSS 0.24635f
C3095 VDD.t300 VSS 0.36953f
C3096 VDD.t299 VSS 0.4927f
C3097 VDD.t298 VSS 0.4927f
C3098 VDD.t297 VSS 2.34033f
C3099 VDD.t383 VSS 2.21716f
C3100 VDD.t375 VSS 0.4927f
C3101 VDD.t373 VSS 0.4927f
C3102 VDD.t387 VSS 2.34033f
C3103 VDD.n139 VSS 2.34033f
C3104 VDD.t269 VSS 0.4927f
C3105 VDD.t271 VSS 0.4927f
C3106 VDD.t295 VSS 0.4927f
C3107 VDD.t273 VSS 1.72446f
C3108 VDD.n140 VSS 2.14106f
C3109 VDD.t385 VSS 0.61588f
C3110 VDD.n141 VSS 0.24635f
C3111 VDD.n142 VSS 0.09238f
C3112 VDD.n143 VSS 0.09658f
C3113 VDD.n144 VSS 0.09846f
C3114 VDD.n145 VSS 0.09846f
C3115 VDD.n146 VSS 0.09846f
C3116 VDD.n147 VSS 0.09658f
C3117 VDD.n148 VSS 0.09238f
C3118 VDD.n149 VSS 0.9854f
C3119 VDD.t281 VSS 0.86223f
C3120 VDD.t171 VSS 0.24635f
C3121 VDD.t293 VSS 0.24635f
C3122 VDD.t486 VSS 0.24635f
C3123 VDD.t275 VSS 0.24635f
C3124 VDD.t488 VSS 0.24635f
C3125 VDD.t291 VSS 0.24635f
C3126 VDD.t490 VSS 0.24635f
C3127 VDD.t283 VSS 0.24635f
C3128 VDD.t343 VSS 0.4927f
C3129 VDD.t341 VSS 0.4927f
C3130 VDD.t393 VSS 1.10858f
C3131 VDD.n150 VSS 0.9854f
C3132 VDD.t277 VSS 0.36953f
C3133 VDD.t279 VSS 0.4927f
C3134 VDD.t285 VSS 0.4927f
C3135 VDD.t287 VSS 0.4927f
C3136 VDD.t289 VSS 0.36953f
C3137 VDD.n151 VSS 0.4166f
C3138 VDD.n152 VSS 0.26107f
C3139 VDD.n153 VSS 0.26107f
C3140 VDD.t149 VSS 0.4927f
C3141 VDD.t470 VSS 2.46351f
C3142 VDD.n154 VSS 5.4668f
C3143 VDD.n155 VSS 4.55749f
C3144 VDD.n156 VSS 0.09238f
C3145 VDD.n157 VSS 0.09658f
C3146 VDD.n158 VSS 0.09846f
C3147 VDD.n159 VSS 0.09846f
C3148 VDD.n160 VSS 0.09846f
C3149 VDD.n161 VSS 0.09658f
C3150 VDD.n162 VSS 0.09238f
C3151 VDD.n163 VSS 3.44891f
C3152 VDD.n164 VSS 4.31114f
C3153 VDD.n165 VSS 3.54164f
C3154 VDD.n166 VSS 4.70892f
C3155 VDD.n167 VSS 0.07845f
C3156 VDD.n168 VSS 0.09719f
C3157 VDD.n169 VSS 0.32305f
C3158 VDD.n170 VSS 0.36664f
C3159 VDD.n171 VSS 0.65811f
C3160 VDD.n172 VSS 0.08745f
C3161 VDD.n173 VSS 0.1281f
C3162 VDD.t394 VSS 0.13636f
C3163 VDD.t342 VSS 0.13399f
C3164 VDD.n174 VSS 0.05526f
C3165 VDD.t344 VSS 0.13399f
C3166 VDD.t346 VSS 0.13399f
C3167 VDD.n175 VSS 0.05569f
C3168 VDD.n176 VSS 0.1474f
C3169 VDD.n177 VSS 0.19658f
C3170 VDD.n178 VSS 0.06159f
C3171 VDD.n179 VSS 0.4927f
C3172 VDD.n180 VSS 0.4927f
C3173 VDD.n181 VSS 0.04972f
C3174 VDD.t388 VSS 0.18549f
C3175 VDD.t374 VSS 0.18549f
C3176 VDD.n182 VSS 0.05526f
C3177 VDD.t376 VSS 0.18549f
C3178 VDD.t378 VSS 0.18884f
C3179 VDD.n183 VSS 0.05569f
C3180 VDD.n184 VSS 0.09074f
C3181 VDD.n185 VSS 0.13252f
C3182 VDD.t274 VSS 0.14065f
C3183 VDD.t296 VSS 0.14065f
C3184 VDD.n186 VSS 0.05526f
C3185 VDD.t272 VSS 0.14065f
C3186 VDD.t270 VSS 0.14314f
C3187 VDD.n187 VSS 0.05569f
C3188 VDD.n188 VSS 0.11907f
C3189 VDD.n189 VSS 0.16332f
C3190 VDD.n190 VSS 0.05543f
C3191 VDD.t384 VSS 0.18881f
C3192 VDD.t386 VSS 0.18884f
C3193 VDD.n191 VSS 0.11985f
C3194 VDD.n192 VSS 0.16467f
C3195 VDD.n193 VSS 0.09854f
C3196 VDD.n194 VSS 0.4927f
C3197 VDD.n195 VSS 0.4927f
C3198 VDD.n196 VSS 0.06775f
C3199 VDD.t312 VSS 0.14065f
C3200 VDD.t306 VSS 0.14065f
C3201 VDD.n197 VSS 0.05526f
C3202 VDD.t310 VSS 0.14065f
C3203 VDD.t308 VSS 0.14314f
C3204 VDD.n198 VSS 0.05569f
C3205 VDD.n199 VSS 0.11907f
C3206 VDD.n200 VSS 0.16824f
C3207 VDD.n201 VSS 0.06775f
C3208 VDD.t485 VSS 0.18416f
C3209 VDD.t240 VSS 0.18749f
C3210 VDD.n202 VSS 0.05569f
C3211 VDD.t481 VSS 0.18416f
C3212 VDD.t483 VSS 0.18416f
C3213 VDD.n203 VSS 0.05526f
C3214 VDD.n204 VSS 0.09794f
C3215 VDD.n205 VSS 0.14051f
C3216 VDD.n206 VSS 0.02464f
C3217 VDD.n207 VSS 0.4927f
C3218 VDD.n208 VSS 0.4927f
C3219 VDD.n209 VSS 0.0882f
C3220 VDD.t169 VSS 0.12708f
C3221 VDD.t465 VSS 0.12708f
C3222 VDD.n210 VSS 0.05526f
C3223 VDD.t467 VSS 0.12708f
C3224 VDD.t469 VSS 0.12932f
C3225 VDD.n211 VSS 0.05569f
C3226 VDD.n212 VSS 0.1474f
C3227 VDD.n213 VSS 0.19658f
C3228 VDD.n214 VSS 0.14288f
C3229 VDD.n215 VSS 0.08499f
C3230 VDD.n216 VSS 0.59084f
C3231 VDD.n217 VSS 1.21257f
C3232 VDD.n218 VSS 0.19864f
C3233 VDD.n219 VSS 0.06612f
C3234 VDD.n220 VSS 0.09658f
C3235 VDD.n221 VSS 0.09238f
C3236 VDD.t359 VSS 0.61588f
C3237 VDD.n222 VSS 0.09238f
C3238 VDD.n223 VSS 0.09658f
C3239 VDD.n224 VSS 0.09846f
C3240 VDD.n225 VSS 0.09658f
C3241 VDD.n226 VSS 0.09238f
C3242 VDD.t100 VSS 2.34033f
C3243 VDD.n227 VSS 0.25989f
C3244 VDD.t261 VSS 0.36953f
C3245 VDD.n228 VSS 0.09238f
C3246 VDD.n229 VSS 0.09658f
C3247 VDD.n230 VSS 0.09846f
C3248 VDD.n231 VSS 0.09658f
C3249 VDD.n232 VSS 0.09238f
C3250 VDD.t166 VSS 0.61588f
C3251 VDD.n233 VSS 0.09238f
C3252 VDD.n234 VSS 0.09658f
C3253 VDD.n235 VSS 0.09846f
C3254 VDD.n236 VSS 0.09658f
C3255 VDD.n237 VSS 0.09238f
C3256 VDD.t109 VSS 0.36953f
C3257 VDD.n238 VSS 0.41705f
C3258 VDD.t63 VSS 0.61588f
C3259 VDD.n239 VSS 0.09238f
C3260 VDD.n240 VSS 0.09658f
C3261 VDD.n241 VSS 0.08265f
C3262 VDD.n242 VSS 0.09658f
C3263 VDD.n243 VSS 0.09238f
C3264 VDD.n244 VSS 4.71473f
C3265 VDD.n245 VSS 3.55019f
C3266 VDD.n246 VSS 1.4781f
C3267 VDD.t401 VSS 0.4927f
C3268 VDD.t454 VSS 0.4927f
C3269 VDD.t452 VSS 0.4927f
C3270 VDD.t347 VSS 2.34033f
C3271 VDD.t65 VSS 0.4927f
C3272 VDD.t67 VSS 0.4927f
C3273 VDD.t69 VSS 0.4927f
C3274 VDD.t71 VSS 0.4927f
C3275 VDD.t73 VSS 0.4927f
C3276 VDD.t75 VSS 0.4927f
C3277 VDD.t77 VSS 1.23175f
C3278 VDD.n247 VSS 2.13751f
C3279 VDD.t31 VSS 1.23175f
C3280 VDD.t33 VSS 0.4927f
C3281 VDD.t35 VSS 0.4927f
C3282 VDD.t37 VSS 0.4927f
C3283 VDD.t39 VSS 0.4927f
C3284 VDD.t41 VSS 0.4927f
C3285 VDD.t43 VSS 0.4927f
C3286 VDD.t45 VSS 0.61588f
C3287 VDD.n248 VSS 2.46351f
C3288 VDD.n249 VSS 0.09238f
C3289 VDD.n250 VSS 0.09658f
C3290 VDD.n251 VSS 0.26654f
C3291 VDD.n252 VSS 0.09846f
C3292 VDD.n253 VSS 0.09846f
C3293 VDD.n254 VSS 0.09658f
C3294 VDD.n255 VSS 0.09238f
C3295 VDD.n256 VSS 2.46351f
C3296 VDD.t0 VSS 2.34033f
C3297 VDD.t97 VSS 0.4927f
C3298 VDD.t98 VSS 0.4927f
C3299 VDD.t57 VSS 0.4927f
C3300 VDD.n257 VSS 1.4781f
C3301 VDD.t117 VSS 0.4927f
C3302 VDD.t119 VSS 0.4927f
C3303 VDD.t121 VSS 1.23175f
C3304 VDD.n258 VSS 2.38386f
C3305 VDD.n259 VSS 0.25989f
C3306 VDD.n260 VSS 0.25989f
C3307 VDD.n261 VSS 0.41306f
C3308 VDD.t164 VSS 2.46351f
C3309 VDD.n262 VSS 3.20256f
C3310 VDD.t353 VSS 1.10858f
C3311 VDD.t403 VSS 0.4927f
C3312 VDD.t444 VSS 0.4927f
C3313 VDD.t456 VSS 0.86223f
C3314 VDD.t111 VSS 0.86223f
C3315 VDD.t115 VSS 0.4927f
C3316 VDD.t113 VSS 0.4927f
C3317 VDD.t107 VSS 0.36953f
C3318 VDD.n263 VSS 0.24635f
C3319 VDD.n264 VSS 0.09238f
C3320 VDD.n265 VSS 0.09658f
C3321 VDD.n266 VSS 0.09846f
C3322 VDD.n267 VSS 0.09846f
C3323 VDD.n268 VSS 0.09846f
C3324 VDD.n269 VSS 0.09658f
C3325 VDD.n270 VSS 0.09238f
C3326 VDD.n271 VSS 3.57209f
C3327 VDD.n272 VSS 6.15877f
C3328 VDD.t411 VSS 0.4927f
C3329 VDD.t409 VSS 0.4927f
C3330 VDD.t405 VSS 0.86223f
C3331 VDD.t450 VSS 0.86223f
C3332 VDD.t142 VSS 0.4927f
C3333 VDD.t144 VSS 0.4927f
C3334 VDD.t61 VSS 1.10858f
C3335 VDD.n273 VSS 3.20256f
C3336 VDD.t460 VSS 2.46351f
C3337 VDD.n274 VSS 0.41306f
C3338 VDD.t458 VSS 0.61588f
C3339 VDD.n275 VSS 3.57209f
C3340 VDD.n276 VSS 0.09238f
C3341 VDD.n277 VSS 0.09658f
C3342 VDD.n278 VSS 0.09846f
C3343 VDD.n279 VSS 0.09846f
C3344 VDD.n280 VSS 0.09846f
C3345 VDD.n281 VSS 0.09658f
C3346 VDD.n282 VSS 0.09238f
C3347 VDD.n283 VSS 0.24635f
C3348 VDD.t263 VSS 0.36953f
C3349 VDD.t407 VSS 0.4927f
C3350 VDD.t414 VSS 0.4927f
C3351 VDD.t416 VSS 1.23175f
C3352 VDD.t99 VSS 0.4927f
C3353 VDD.t59 VSS 0.4927f
C3354 VDD.t58 VSS 0.4927f
C3355 VDD.n284 VSS 1.4781f
C3356 VDD.n285 VSS 2.38386f
C3357 VDD.n286 VSS 0.25989f
C3358 VDD.n287 VSS 0.25599f
C3359 VDD.t365 VSS 0.4927f
C3360 VDD.t363 VSS 0.4927f
C3361 VDD.t355 VSS 0.4927f
C3362 VDD.t357 VSS 0.4927f
C3363 VDD.t367 VSS 0.4927f
C3364 VDD.t361 VSS 0.4927f
C3365 VDD.t369 VSS 1.23175f
C3366 VDD.n288 VSS 2.13751f
C3367 VDD.t86 VSS 1.23175f
C3368 VDD.t82 VSS 0.4927f
C3369 VDD.t84 VSS 0.4927f
C3370 VDD.t88 VSS 0.4927f
C3371 VDD.t90 VSS 0.4927f
C3372 VDD.t92 VSS 0.4927f
C3373 VDD.t80 VSS 0.4927f
C3374 VDD.t94 VSS 0.61588f
C3375 VDD.n289 VSS 2.46351f
C3376 VDD.n290 VSS 0.09238f
C3377 VDD.n291 VSS 0.09658f
C3378 VDD.n292 VSS 0.09846f
C3379 VDD.n293 VSS 0.09846f
C3380 VDD.n294 VSS 0.09846f
C3381 VDD.n295 VSS 0.09658f
C3382 VDD.n296 VSS 0.09238f
C3383 VDD.n297 VSS 2.46351f
C3384 VDD.t156 VSS 2.34033f
C3385 VDD.t25 VSS 0.4927f
C3386 VDD.t442 VSS 0.4927f
C3387 VDD.t462 VSS 0.4927f
C3388 VDD.n298 VSS 1.4781f
C3389 VDD.n299 VSS 3.53843f
C3390 VDD.n300 VSS 4.70892f
C3391 VDD.n301 VSS 0.07923f
C3392 VDD.n302 VSS 0.1149f
C3393 VDD.n303 VSS 0.59084f
C3394 VDD.t439 VSS 0.12932f
C3395 VDD.t441 VSS 0.12708f
C3396 VDD.n304 VSS 0.05569f
C3397 VDD.t380 VSS 0.12708f
C3398 VDD.t382 VSS 0.12708f
C3399 VDD.n305 VSS 0.05526f
C3400 VDD.n306 VSS 0.1474f
C3401 VDD.n307 VSS 0.19658f
C3402 VDD.n308 VSS 0.4927f
C3403 VDD.t201 VSS 0.14314f
C3404 VDD.t195 VSS 0.14065f
C3405 VDD.n309 VSS 0.05569f
C3406 VDD.t199 VSS 0.14065f
C3407 VDD.t197 VSS 0.14065f
C3408 VDD.n310 VSS 0.05526f
C3409 VDD.n311 VSS 0.11907f
C3410 VDD.n312 VSS 0.16824f
C3411 VDD.n313 VSS 0.4927f
C3412 VDD.t217 VSS 0.14314f
C3413 VDD.t215 VSS 0.14065f
C3414 VDD.n314 VSS 0.05569f
C3415 VDD.t211 VSS 0.14065f
C3416 VDD.t213 VSS 0.14065f
C3417 VDD.n315 VSS 0.05526f
C3418 VDD.n316 VSS 0.11907f
C3419 VDD.n317 VSS 0.16332f
C3420 VDD.n318 VSS 0.4927f
C3421 VDD.n319 VSS 0.08745f
C3422 VDD.n320 VSS 0.18208f
C3423 VDD.n321 VSS 0.07845f
C3424 VDD.n322 VSS 0.09846f
C3425 VDD.n323 VSS 0.09658f
C3426 VDD.n324 VSS 4.70892f
C3427 VDD.n325 VSS 0.09238f
C3428 VDD.n326 VSS 3.54165f
C3429 VDD.n327 VSS 0.26107f
C3430 VDD.n328 VSS 4.55749f
C3431 VDD.n329 VSS 0.09238f
C3432 VDD.n330 VSS 0.09846f
C3433 VDD.n331 VSS 0.09846f
C3434 VDD.n332 VSS 0.09846f
C3435 VDD.n333 VSS 0.09658f
C3436 VDD.n334 VSS 0.09238f
C3437 VDD.t257 VSS 1.72446f
C3438 VDD.t250 VSS 0.4927f
C3439 VDD.t252 VSS 0.4927f
C3440 VDD.t254 VSS 1.10858f
C3441 VDD.t226 VSS 0.24635f
C3442 VDD.n335 VSS 0.26107f
C3443 VDD.t212 VSS 1.72446f
C3444 VDD.t51 VSS 2.21716f
C3445 VDD.t472 VSS 0.24635f
C3446 VDD.t224 VSS 0.24635f
C3447 VDD.t474 VSS 0.24635f
C3448 VDD.t222 VSS 0.24635f
C3449 VDD.t21 VSS 0.24635f
C3450 VDD.t220 VSS 0.24635f
C3451 VDD.t23 VSS 0.24635f
C3452 VDD.t218 VSS 0.86223f
C3453 VDD.n336 VSS 0.9854f
C3454 VDD.t349 VSS 0.4927f
C3455 VDD.t351 VSS 0.4927f
C3456 VDD.t133 VSS 0.4927f
C3457 VDD.t135 VSS 2.34033f
C3458 VDD.t210 VSS 0.4927f
C3459 VDD.t214 VSS 0.4927f
C3460 VDD.t216 VSS 0.4927f
C3461 VDD.n337 VSS 2.34033f
C3462 VDD.n338 VSS 0.09238f
C3463 VDD.n339 VSS 0.09238f
C3464 VDD.n340 VSS 0.09658f
C3465 VDD.n341 VSS 0.09846f
C3466 VDD.n342 VSS 0.09846f
C3467 VDD.n343 VSS 0.09846f
C3468 VDD.n344 VSS 0.09846f
C3469 VDD.n345 VSS 0.09846f
C3470 VDD.n346 VSS 0.09658f
C3471 VDD.n347 VSS 0.09238f
C3472 VDD.t209 VSS 2.34033f
C3473 VDD.t208 VSS 0.4927f
C3474 VDD.t207 VSS 0.4927f
C3475 VDD.t206 VSS 0.36953f
C3476 VDD.n348 VSS 0.24635f
C3477 VDD.t205 VSS 0.36953f
C3478 VDD.t204 VSS 0.4927f
C3479 VDD.t203 VSS 0.4927f
C3480 VDD.t202 VSS 2.34033f
C3481 VDD.t1 VSS 2.21716f
C3482 VDD.t192 VSS 0.86223f
C3483 VDD.n349 VSS 0.09238f
C3484 VDD.n350 VSS 0.09846f
C3485 VDD.n351 VSS 0.09846f
C3486 VDD.n352 VSS 0.09846f
C3487 VDD.n353 VSS 0.09846f
C3488 VDD.n354 VSS 0.09658f
C3489 VDD.n355 VSS 0.09238f
C3490 VDD.t381 VSS 1.72446f
C3491 VDD.t446 VSS 0.24635f
C3492 VDD.t184 VSS 0.24635f
C3493 VDD.t448 VSS 0.24635f
C3494 VDD.t190 VSS 0.24635f
C3495 VDD.t265 VSS 0.24635f
C3496 VDD.t188 VSS 0.24635f
C3497 VDD.t267 VSS 0.24635f
C3498 VDD.t186 VSS 0.24635f
C3499 VDD.t379 VSS 0.4927f
C3500 VDD.t440 VSS 0.4927f
C3501 VDD.t438 VSS 1.10858f
C3502 VDD.n356 VSS 0.9854f
C3503 VDD.t176 VSS 0.36953f
C3504 VDD.t178 VSS 0.4927f
C3505 VDD.t180 VSS 0.4927f
C3506 VDD.t182 VSS 0.4927f
C3507 VDD.t174 VSS 0.36953f
C3508 VDD.n357 VSS 0.4166f
C3509 VDD.n358 VSS 0.26107f
C3510 VDD.n359 VSS 0.41929f
C3511 VDD.n360 VSS 4.31114f
C3512 VDD.n361 VSS 0.09238f
C3513 VDD.n362 VSS 0.09846f
C3514 VDD.n363 VSS 0.26654f
C3515 VDD.n364 VSS 3.55385f
C3516 VDD.n365 VSS 4.71473f
C3517 VDD.n366 VSS 0.08265f
C3518 VDD.n367 VSS 0.09658f
C3519 VDD.n368 VSS 0.09658f
C3520 VDD.n369 VSS 0.09238f
C3521 VDD.n370 VSS 3.44891f
C3522 VDD.t259 VSS 0.61588f
C3523 VDD.t397 VSS 0.4927f
C3524 VDD.t395 VSS 2.46351f
C3525 VDD.n371 VSS 5.4668f
C3526 VDD.n372 VSS 4.55749f
C3527 VDD.n373 VSS 0.09238f
C3528 VDD.n374 VSS 0.09658f
C3529 VDD.n375 VSS 0.09658f
C3530 VDD.n376 VSS 0.09658f
C3531 VDD.n377 VSS 0.09238f
C3532 VDD.n378 VSS 0.9854f
C3533 VDD.t162 VSS 0.4927f
C3534 VDD.t160 VSS 0.4927f
C3535 VDD.t429 VSS 0.4927f
C3536 VDD.t427 VSS 2.34033f
C3537 VDD.n379 VSS 2.34033f
C3538 VDD.t196 VSS 0.4927f
C3539 VDD.t198 VSS 0.4927f
C3540 VDD.t194 VSS 0.4927f
C3541 VDD.t200 VSS 1.72446f
C3542 VDD.n380 VSS 2.14106f
C3543 VDD.t3 VSS 0.61588f
C3544 VDD.n381 VSS 0.24635f
C3545 VDD.n382 VSS 0.09238f
C3546 VDD.n383 VSS 0.09658f
C3547 VDD.n384 VSS 0.09658f
C3548 VDD.n385 VSS 0.09658f
C3549 VDD.n386 VSS 0.09238f
C3550 VDD.n387 VSS 0.24635f
C3551 VDD.t49 VSS 0.61588f
C3552 VDD.n388 VSS 2.14106f
C3553 VDD.n389 VSS 0.26107f
C3554 VDD.n390 VSS 0.26107f
C3555 VDD.n391 VSS 0.4166f
C3556 VDD.t228 VSS 0.36953f
C3557 VDD.t230 VSS 0.4927f
C3558 VDD.t232 VSS 0.4927f
C3559 VDD.t234 VSS 0.4927f
C3560 VDD.t236 VSS 0.36953f
C3561 VDD.n392 VSS 0.9854f
C3562 VDD.n393 VSS 0.09238f
C3563 VDD.n394 VSS 0.09658f
C3564 VDD.n395 VSS 0.09658f
C3565 VDD.n396 VSS 0.09658f
C3566 VDD.n397 VSS 0.09238f
C3567 VDD.n398 VSS 5.4668f
C3568 VDD.t436 VSS 2.46351f
C3569 VDD.t140 VSS 0.4927f
C3570 VDD.t138 VSS 0.61588f
C3571 VDD.n399 VSS 3.44891f
C3572 VDD.n400 VSS 4.31114f
C3573 VDD.n401 VSS 0.09238f
C3574 VDD.n402 VSS 0.09658f
C3575 VDD.n403 VSS 0.0846f
C3576 VDD.n404 VSS 0.09719f
C3577 VDD.n405 VSS 0.32305f
C3578 VDD.t139 VSS 0.12932f
C3579 VDD.t141 VSS 0.12708f
C3580 VDD.n406 VSS 0.05569f
C3581 VDD.t437 VSS 0.18401f
C3582 VDD.n407 VSS 0.15404f
C3583 VDD.n408 VSS 0.34449f
C3584 VDD.n409 VSS 0.36664f
C3585 VDD.n410 VSS 0.65811f
C3586 VDD.n411 VSS 0.4927f
C3587 VDD.n412 VSS 0.1281f
C3588 VDD.t258 VSS 0.13399f
C3589 VDD.t251 VSS 0.13399f
C3590 VDD.n413 VSS 0.05569f
C3591 VDD.t253 VSS 0.13399f
C3592 VDD.t255 VSS 0.13636f
C3593 VDD.n414 VSS 0.05526f
C3594 VDD.n415 VSS 0.1474f
C3595 VDD.n416 VSS 0.19658f
C3596 VDD.n417 VSS 0.06159f
C3597 VDD.t473 VSS 0.18749f
C3598 VDD.t475 VSS 0.18416f
C3599 VDD.n418 VSS 0.05569f
C3600 VDD.t22 VSS 0.18416f
C3601 VDD.t24 VSS 0.18416f
C3602 VDD.n419 VSS 0.05526f
C3603 VDD.n420 VSS 0.1474f
C3604 VDD.n421 VSS 0.21973f
C3605 VDD.t237 VSS 0.1055f
C3606 VDD.t235 VSS 0.1055f
C3607 VDD.n422 VSS 0.05569f
C3608 VDD.t233 VSS 0.1055f
C3609 VDD.t231 VSS 0.1055f
C3610 VDD.n423 VSS 0.05526f
C3611 VDD.n424 VSS 0.028f
C3612 VDD.t229 VSS 0.1055f
C3613 VDD.t227 VSS 0.1055f
C3614 VDD.n425 VSS 0.05526f
C3615 VDD.n426 VSS 0.01586f
C3616 VDD.t225 VSS 0.1055f
C3617 VDD.t223 VSS 0.1055f
C3618 VDD.n427 VSS 0.05526f
C3619 VDD.n428 VSS 0.01586f
C3620 VDD.t221 VSS 0.1055f
C3621 VDD.t219 VSS 0.10808f
C3622 VDD.n429 VSS 0.05526f
C3623 VDD.n430 VSS 0.21553f
C3624 VDD.n431 VSS 0.15565f
C3625 VDD.t350 VSS 0.18884f
C3626 VDD.t352 VSS 0.18549f
C3627 VDD.n432 VSS 0.05569f
C3628 VDD.t134 VSS 0.18549f
C3629 VDD.t136 VSS 0.18549f
C3630 VDD.n433 VSS 0.05526f
C3631 VDD.n434 VSS 0.09074f
C3632 VDD.n435 VSS 0.13252f
C3633 VDD.n436 VSS 0.04972f
C3634 VDD.n437 VSS 0.4927f
C3635 VDD.n438 VSS 0.4927f
C3636 VDD.n439 VSS 0.05543f
C3637 VDD.t50 VSS 0.18884f
C3638 VDD.t52 VSS 0.18881f
C3639 VDD.n440 VSS 0.11985f
C3640 VDD.n441 VSS 0.16467f
C3641 VDD.n442 VSS 0.09854f
C3642 VDD.t2 VSS 0.18746f
C3643 VDD.t4 VSS 0.18749f
C3644 VDD.n443 VSS 0.122f
C3645 VDD.n444 VSS 0.16565f
C3646 VDD.n445 VSS 0.06775f
C3647 VDD.n446 VSS 0.4927f
C3648 VDD.n447 VSS 0.4927f
C3649 VDD.n448 VSS 0.06775f
C3650 VDD.t428 VSS 0.18749f
C3651 VDD.t430 VSS 0.18416f
C3652 VDD.n449 VSS 0.05569f
C3653 VDD.t161 VSS 0.18416f
C3654 VDD.t163 VSS 0.18416f
C3655 VDD.n450 VSS 0.05526f
C3656 VDD.n451 VSS 0.09794f
C3657 VDD.n452 VSS 0.14051f
C3658 VDD.n453 VSS 0.02464f
C3659 VDD.t447 VSS 0.18549f
C3660 VDD.t449 VSS 0.18549f
C3661 VDD.n454 VSS 0.05537f
C3662 VDD.t266 VSS 0.18549f
C3663 VDD.t268 VSS 0.18884f
C3664 VDD.n455 VSS 0.05548f
C3665 VDD.n456 VSS 0.14749f
C3666 VDD.n457 VSS 0.20071f
C3667 VDD.t193 VSS 0.10808f
C3668 VDD.t185 VSS 0.1055f
C3669 VDD.n458 VSS 0.05569f
C3670 VDD.t191 VSS 0.1055f
C3671 VDD.t189 VSS 0.1055f
C3672 VDD.n459 VSS 0.05526f
C3673 VDD.n460 VSS 0.028f
C3674 VDD.t187 VSS 0.1055f
C3675 VDD.t175 VSS 0.1055f
C3676 VDD.n461 VSS 0.05526f
C3677 VDD.n462 VSS 0.01586f
C3678 VDD.t183 VSS 0.1055f
C3679 VDD.t181 VSS 0.1055f
C3680 VDD.n463 VSS 0.05526f
C3681 VDD.n464 VSS 0.01586f
C3682 VDD.t179 VSS 0.1055f
C3683 VDD.t177 VSS 0.1055f
C3684 VDD.n465 VSS 0.05526f
C3685 VDD.n466 VSS 0.22729f
C3686 VDD.n467 VSS 0.17084f
C3687 VDD.n468 VSS 0.0882f
C3688 VDD.n469 VSS 0.4927f
C3689 VDD.n470 VSS 0.4927f
C3690 VDD.n471 VSS 0.14288f
C3691 VDD.n472 VSS 0.08499f
C3692 VDD.t396 VSS 0.13636f
C3693 VDD.t398 VSS 0.13399f
C3694 VDD.n473 VSS 0.05569f
C3695 VDD.t260 VSS 0.19092f
C3696 VDD.n474 VSS 0.15404f
C3697 VDD.n475 VSS 0.33111f
C3698 VDD.n476 VSS 1.15032f
C3699 VDD.n477 VSS 18.3762f
C3700 VDD.n478 VSS 0.05783f
C3701 VDD.t262 VSS 0.17261f
C3702 VDD.t264 VSS 0.17261f
C3703 VDD.n479 VSS 0.08706f
C3704 VDD.t143 VSS 0.137f
C3705 VDD.t451 VSS 0.13942f
C3706 VDD.n480 VSS 0.05569f
C3707 VDD.t62 VSS 0.13942f
C3708 VDD.t145 VSS 0.137f
C3709 VDD.n481 VSS 0.05526f
C3710 VDD.n482 VSS 0.0278f
C3711 VDD.n483 VSS 0.14265f
C3712 VDD.t415 VSS 0.08009f
C3713 VDD.t422 VSS 0.08009f
C3714 VDD.n484 VSS 0.05569f
C3715 VDD.t413 VSS 0.08009f
C3716 VDD.t423 VSS 0.08009f
C3717 VDD.n485 VSS 0.05526f
C3718 VDD.n486 VSS 0.028f
C3719 VDD.t412 VSS 0.08009f
C3720 VDD.t424 VSS 0.08009f
C3721 VDD.n487 VSS 0.05526f
C3722 VDD.n488 VSS 0.01586f
C3723 VDD.t426 VSS 0.08142f
C3724 VDD.t425 VSS 0.08009f
C3725 VDD.n489 VSS 0.05526f
C3726 VDD.n490 VSS 0.01586f
C3727 VDD.n491 VSS 0.0489f
C3728 VDD.n492 VSS 0.1427f
C3729 VDD.n493 VSS 0.0855f
C3730 VDD.t165 VSS 0.173f
C3731 VDD.t167 VSS 0.17303f
C3732 VDD.n494 VSS 0.10077f
C3733 VDD.t457 VSS 0.14247f
C3734 VDD.t445 VSS 0.13999f
C3735 VDD.n495 VSS 0.05569f
C3736 VDD.t404 VSS 0.13999f
C3737 VDD.t354 VSS 0.14247f
C3738 VDD.n496 VSS 0.05526f
C3739 VDD.n497 VSS 0.05696f
C3740 VDD.n498 VSS 0.11987f
C3741 VDD.t153 VSS 0.17151f
C3742 VDD.t154 VSS 0.17151f
C3743 VDD.n499 VSS 0.08706f
C3744 VDD.t453 VSS 0.14881f
C3745 VDD.t348 VSS 0.15146f
C3746 VDD.n500 VSS 0.05569f
C3747 VDD.t402 VSS 0.15146f
C3748 VDD.t455 VSS 0.14881f
C3749 VDD.n501 VSS 0.05526f
C3750 VDD.n502 VSS 0.09299f
C3751 VDD.n503 VSS 0.26165f
C3752 VDD.t34 VSS 0.06301f
C3753 VDD.t32 VSS 0.06401f
C3754 VDD.n504 VSS 0.05569f
C3755 VDD.t38 VSS 0.06301f
C3756 VDD.t36 VSS 0.06301f
C3757 VDD.n505 VSS 0.05526f
C3758 VDD.n506 VSS 0.028f
C3759 VDD.t42 VSS 0.06301f
C3760 VDD.t40 VSS 0.06301f
C3761 VDD.n507 VSS 0.05526f
C3762 VDD.n508 VSS 0.01586f
C3763 VDD.t46 VSS 0.06401f
C3764 VDD.t44 VSS 0.06301f
C3765 VDD.n509 VSS 0.05526f
C3766 VDD.n510 VSS 0.16025f
C3767 VDD.t155 VSS 0.1715f
C3768 VDD.t137 VSS 0.17153f
C3769 VDD.n511 VSS 0.06818f
C3770 VDD.n512 VSS 0.19779f
C3771 VDD.n513 VSS 0.10734f
C3772 VDD.n514 VSS 0.17732f
C3773 VDD.t78 VSS 0.06037f
C3774 VDD.t76 VSS 0.05944f
C3775 VDD.n515 VSS 0.05526f
C3776 VDD.n516 VSS 0.13685f
C3777 VDD.t66 VSS 0.05944f
C3778 VDD.t64 VSS 0.06037f
C3779 VDD.n517 VSS 0.05569f
C3780 VDD.t70 VSS 0.05944f
C3781 VDD.t68 VSS 0.05944f
C3782 VDD.n518 VSS 0.05526f
C3783 VDD.n519 VSS 0.028f
C3784 VDD.t74 VSS 0.05944f
C3785 VDD.t72 VSS 0.05944f
C3786 VDD.n520 VSS 0.05526f
C3787 VDD.n521 VSS 0.01274f
C3788 VDD.n522 VSS 0.13363f
C3789 VDD.n523 VSS 0.16796f
C3790 VDD.t158 VSS 0.17302f
C3791 VDD.t159 VSS 0.17302f
C3792 VDD.n524 VSS 0.18497f
C3793 VDD.n525 VSS 0.23423f
C3794 VDD.n526 VSS 0.14188f
C3795 VDD.t124 VSS 0.08307f
C3796 VDD.t123 VSS 0.08307f
C3797 VDD.n527 VSS 0.05569f
C3798 VDD.t126 VSS 0.08307f
C3799 VDD.t125 VSS 0.08307f
C3800 VDD.n528 VSS 0.05526f
C3801 VDD.n529 VSS 0.028f
C3802 VDD.t128 VSS 0.08307f
C3803 VDD.t127 VSS 0.08307f
C3804 VDD.n530 VSS 0.05526f
C3805 VDD.n531 VSS 0.01586f
C3806 VDD.t130 VSS 0.08446f
C3807 VDD.t129 VSS 0.08307f
C3808 VDD.n532 VSS 0.05526f
C3809 VDD.n533 VSS 0.01586f
C3810 VDD.n534 VSS 0.1293f
C3811 VDD.n535 VSS 0.1427f
C3812 VDD.n536 VSS 0.11055f
C3813 VDD.t122 VSS 0.08446f
C3814 VDD.t120 VSS 0.08307f
C3815 VDD.n537 VSS 0.05526f
C3816 VDD.n538 VSS 0.02469f
C3817 VDD.t118 VSS 0.08307f
C3818 VDD.t110 VSS 0.08307f
C3819 VDD.n539 VSS 0.05526f
C3820 VDD.n540 VSS 0.01586f
C3821 VDD.t108 VSS 0.08307f
C3822 VDD.t114 VSS 0.08307f
C3823 VDD.n541 VSS 0.05526f
C3824 VDD.n542 VSS 0.01586f
C3825 VDD.t116 VSS 0.08307f
C3826 VDD.t112 VSS 0.08307f
C3827 VDD.n543 VSS 0.05526f
C3828 VDD.n544 VSS 0.07422f
C3829 VDD.n545 VSS 0.07942f
C3830 VDD.n546 VSS 0.17755f
C3831 VDD.t459 VSS 0.16823f
C3832 VDD.t461 VSS 0.16826f
C3833 VDD.n547 VSS 0.14938f
C3834 VDD.n548 VSS 0.26765f
C3835 VDD.n549 VSS 0.09018f
C3836 VDD.t418 VSS 0.08009f
C3837 VDD.t417 VSS 0.08009f
C3838 VDD.n550 VSS 0.05569f
C3839 VDD.t420 VSS 0.08009f
C3840 VDD.t408 VSS 0.08009f
C3841 VDD.n551 VSS 0.05526f
C3842 VDD.n552 VSS 0.028f
C3843 VDD.t421 VSS 0.08009f
C3844 VDD.t419 VSS 0.08009f
C3845 VDD.n553 VSS 0.05526f
C3846 VDD.n554 VSS 0.01586f
C3847 VDD.t406 VSS 0.08142f
C3848 VDD.t410 VSS 0.08009f
C3849 VDD.n555 VSS 0.05526f
C3850 VDD.n556 VSS 0.01586f
C3851 VDD.n557 VSS 0.09724f
C3852 VDD.n558 VSS 0.11018f
C3853 VDD.n559 VSS 0.06989f
C3854 VDD.t339 VSS 0.16825f
C3855 VDD.t340 VSS 0.16825f
C3856 VDD.n560 VSS 0.18497f
C3857 VDD.n561 VSS 0.26543f
C3858 VDD.n562 VSS 0.18356f
C3859 VDD.t95 VSS 0.06538f
C3860 VDD.t81 VSS 0.06435f
C3861 VDD.n563 VSS 0.05526f
C3862 VDD.n564 VSS 0.13685f
C3863 VDD.t83 VSS 0.06435f
C3864 VDD.t87 VSS 0.06538f
C3865 VDD.n565 VSS 0.05569f
C3866 VDD.t89 VSS 0.06435f
C3867 VDD.t85 VSS 0.06435f
C3868 VDD.n566 VSS 0.05526f
C3869 VDD.n567 VSS 0.028f
C3870 VDD.t93 VSS 0.06435f
C3871 VDD.t91 VSS 0.06435f
C3872 VDD.n568 VSS 0.05526f
C3873 VDD.n569 VSS 0.01274f
C3874 VDD.n570 VSS 0.13363f
C3875 VDD.n571 VSS 0.17108f
C3876 VDD.n572 VSS 0.17173f
C3877 VDD.t366 VSS 0.06631f
C3878 VDD.t360 VSS 0.06738f
C3879 VDD.n573 VSS 0.05569f
C3880 VDD.t356 VSS 0.06631f
C3881 VDD.t364 VSS 0.06631f
C3882 VDD.n574 VSS 0.05526f
C3883 VDD.n575 VSS 0.028f
C3884 VDD.t368 VSS 0.06631f
C3885 VDD.t358 VSS 0.06631f
C3886 VDD.n576 VSS 0.05526f
C3887 VDD.n577 VSS 0.01586f
C3888 VDD.t370 VSS 0.06738f
C3889 VDD.t362 VSS 0.06631f
C3890 VDD.n578 VSS 0.05526f
C3891 VDD.n579 VSS 0.16025f
C3892 VDD.t476 VSS 0.17259f
C3893 VDD.t477 VSS 0.17263f
C3894 VDD.n580 VSS 0.06818f
C3895 VDD.n581 VSS 0.19779f
C3896 VDD.n582 VSS 0.11046f
C3897 VDD.t443 VSS 0.14346f
C3898 VDD.t463 VSS 0.14601f
C3899 VDD.n583 VSS 0.05569f
C3900 VDD.t157 VSS 0.14601f
C3901 VDD.t26 VSS 0.14346f
C3902 VDD.n584 VSS 0.05526f
C3903 VDD.n585 VSS 0.08475f
C3904 VDD.n586 VSS 0.15782f
C3905 VDD.n587 VSS 15.1395f
C3906 VDD.n588 VSS 14.275f
C3907 VDD.n589 VSS 7.67079f
C3908 VDD.n590 VSS 18.1405f
C3909 VDD.n591 VSS 17.9249f
C3910 E_CAPTURE_CLKB.n0 VSS 0.04638f
C3911 E_CAPTURE_CLKB.n1 VSS 0.04638f
C3912 E_CAPTURE_CLKB.n2 VSS 0.04638f
C3913 E_CAPTURE_CLKB.n3 VSS 0.04638f
C3914 E_CAPTURE_CLKB.n4 VSS 0.13498f
C3915 E_CAPTURE_CLKB.n5 VSS 0.06672f
C3916 E_CAPTURE_CLKB.n6 VSS 0.07152f
C3917 E_CAPTURE_CLKB.n7 VSS 0.07152f
C3918 E_CAPTURE_CLKB.n8 VSS 0.07152f
C3919 E_CAPTURE_CLKB.n9 VSS 0.07152f
C3920 E_CAPTURE_CLKB.n10 VSS 0.07152f
C3921 E_CAPTURE_CLKB.n11 VSS 0.07152f
C3922 E_CAPTURE_CLKB.n12 VSS 0.06759f
C3923 E_CAPTURE_CLKB.n13 VSS 0.29448f
C3924 E_CAPTURE_CLKB.n14 VSS 0.04638f
C3925 E_CAPTURE_CLKB.n15 VSS 0.07152f
C3926 E_CAPTURE_CLKB.n16 VSS 0.13498f
C3927 E_CAPTURE_CLKB.n17 VSS 0.06672f
C3928 E_CAPTURE_CLKB.n18 VSS 0.07152f
C3929 E_CAPTURE_CLKB.n19 VSS 0.07152f
C3930 E_CAPTURE_CLKB.n20 VSS 0.07152f
C3931 E_CAPTURE_CLKB.n21 VSS 0.04638f
C3932 E_CAPTURE_CLKB.n22 VSS 0.04638f
C3933 E_CAPTURE_CLKB.n23 VSS 0.04638f
C3934 E_CAPTURE_CLKB.n24 VSS 0.07152f
C3935 E_CAPTURE_CLKB.n25 VSS 0.07152f
C3936 E_CAPTURE_CLKB.n26 VSS 0.06759f
C3937 E_CAPTURE_CLKB.n27 VSS 0.11864f
C3938 E_CAPTURE_CLKB.n28 VSS 3.28482f
C3939 O_CAPTURE_CLKB.n0 VSS 0.04837f
C3940 O_CAPTURE_CLKB.n1 VSS 0.04837f
C3941 O_CAPTURE_CLKB.n2 VSS 0.04837f
C3942 O_CAPTURE_CLKB.n3 VSS 0.04837f
C3943 O_CAPTURE_CLKB.n4 VSS 0.14078f
C3944 O_CAPTURE_CLKB.n5 VSS 0.06958f
C3945 O_CAPTURE_CLKB.n6 VSS 0.07459f
C3946 O_CAPTURE_CLKB.n7 VSS 0.07459f
C3947 O_CAPTURE_CLKB.n8 VSS 0.07459f
C3948 O_CAPTURE_CLKB.n9 VSS 0.07459f
C3949 O_CAPTURE_CLKB.n10 VSS 0.07459f
C3950 O_CAPTURE_CLKB.n11 VSS 0.07459f
C3951 O_CAPTURE_CLKB.n12 VSS 0.07049f
C3952 O_CAPTURE_CLKB.n13 VSS 0.30712f
C3953 O_CAPTURE_CLKB.n14 VSS 0.04837f
C3954 O_CAPTURE_CLKB.n15 VSS 0.07459f
C3955 O_CAPTURE_CLKB.n16 VSS 0.14078f
C3956 O_CAPTURE_CLKB.n17 VSS 0.06958f
C3957 O_CAPTURE_CLKB.n18 VSS 0.07459f
C3958 O_CAPTURE_CLKB.n19 VSS 0.07459f
C3959 O_CAPTURE_CLKB.n20 VSS 0.07459f
C3960 O_CAPTURE_CLKB.n21 VSS 0.04837f
C3961 O_CAPTURE_CLKB.n22 VSS 0.04837f
C3962 O_CAPTURE_CLKB.n23 VSS 0.04837f
C3963 O_CAPTURE_CLKB.n24 VSS 0.07459f
C3964 O_CAPTURE_CLKB.n25 VSS 0.07459f
C3965 O_CAPTURE_CLKB.n26 VSS 0.07049f
C3966 O_CAPTURE_CLKB.n27 VSS 0.12373f
C3967 O_CAPTURE_CLKB.n28 VSS 7.45663f
C3968 EVEN_Q.t1 VSS 1.30833f
C3969 EVEN_Q.t0 VSS 0.31666f
C3970 EVEN_Q.t4 VSS 0.31666f
C3971 EVEN_Q.n0 VSS 0.95179f
C3972 EVEN_Q.n1 VSS 0.46942f
C3973 EVEN_Q.t5 VSS 1.30323f
C3974 EVEN_Q.n2 VSS 1.50424f
C3975 EVEN_Q.t6 VSS 0.31666f
C3976 EVEN_Q.t3 VSS 0.31666f
C3977 EVEN_Q.n3 VSS 0.94983f
C3978 EVEN_Q.t2 VSS 1.29902f
C3979 EVEN_Q.n4 VSS 0.478f
C3980 EVEN_Q.n5 VSS 2.99553f
C3981 EVEN_QB.t0 VSS 1.23849f
C3982 EVEN_QB.t2 VSS 0.30028f
C3983 EVEN_QB.t1 VSS 0.30028f
C3984 EVEN_QB.n0 VSS 0.90047f
C3985 EVEN_QB.n1 VSS 0.44411f
C3986 EVEN_QB.t5 VSS 1.23367f
C3987 EVEN_QB.n2 VSS 1.42314f
C3988 EVEN_QB.t6 VSS 0.30028f
C3989 EVEN_QB.t4 VSS 0.30028f
C3990 EVEN_QB.n3 VSS 0.89862f
C3991 EVEN_QB.t3 VSS 1.22968f
C3992 EVEN_QB.n4 VSS 0.45223f
C3993 EVEN_QB.n5 VSS 4.71698f
C3994 ODD_QB.t6 VSS 1.12327f
C3995 ODD_QB.t3 VSS 0.28473f
C3996 ODD_QB.t1 VSS 0.28473f
C3997 ODD_QB.n0 VSS 0.8045f
C3998 ODD_QB.n1 VSS 0.39678f
C3999 ODD_QB.t0 VSS 1.11896f
C4000 ODD_QB.n2 VSS 1.21079f
C4001 ODD_QB.t2 VSS 0.28473f
C4002 ODD_QB.t5 VSS 0.28473f
C4003 ODD_QB.n3 VSS 0.80285f
C4004 ODD_QB.t4 VSS 1.1154f
C4005 ODD_QB.n4 VSS 0.41162f
C4006 ODD_QB.n5 VSS 4.3519f
C4007 ODD_Q.t3 VSS 1.33923f
C4008 ODD_Q.t6 VSS 0.326f
C4009 ODD_Q.t5 VSS 0.326f
C4010 ODD_Q.n0 VSS 0.97244f
C4011 ODD_Q.n1 VSS 0.47961f
C4012 ODD_Q.t1 VSS 1.33402f
C4013 ODD_Q.n2 VSS 1.51482f
C4014 ODD_Q.t4 VSS 0.326f
C4015 ODD_Q.t0 VSS 0.326f
C4016 ODD_Q.n3 VSS 0.97044f
C4017 ODD_Q.t2 VSS 1.32972f
C4018 ODD_Q.n4 VSS 0.48981f
C4019 ODD_Q.n5 VSS 2.90226f
C4020 FE_E_N.n0 VSS 0.03132f
C4021 FE_E_N.n1 VSS 0.10819f
C4022 FE_E_N.n2 VSS 0.05348f
C4023 FE_E_N.n3 VSS 0.05732f
C4024 FE_E_N.n4 VSS 0.05732f
C4025 FE_E_N.n5 VSS 0.10819f
C4026 FE_E_N.n6 VSS 0.05348f
C4027 FE_E_N.n7 VSS 0.05732f
C4028 FE_E_N.n8 VSS 0.05732f
C4029 FE_E_N.n9 VSS 0.05732f
C4030 FE_E_N.n10 VSS 0.05732f
C4031 FE_E_N.n11 VSS 0.03132f
C4032 FE_E_N.n12 VSS 0.2044f
C4033 FE_E_N.n13 VSS 0.05272f
C4034 FE_E_N.n14 VSS 0.05732f
C4035 FE_E_N.n15 VSS 0.05732f
C4036 FE_E_N.n16 VSS 0.05272f
C4037 FE_E_N.n17 VSS 0.15787f
C4038 FE_E_N.n18 VSS 5.61121f
C4039 FE_E_N.t1 VSS 0.53566f
C4040 FE_E_N.t2 VSS 0.18186f
C4041 FE_E_N.t6 VSS 0.18186f
C4042 FE_E_N.n19 VSS 0.33898f
C4043 FE_E_N.n20 VSS 0.31657f
C4044 FE_E_N.t3 VSS 0.53131f
C4045 FE_E_N.t0 VSS 0.53536f
C4046 FE_E_N.t4 VSS 0.18186f
C4047 FE_E_N.t5 VSS 0.18186f
C4048 FE_E_N.n21 VSS 0.33629f
C4049 FE_E_N.n22 VSS 0.1704f
C4050 FE_E_N.n23 VSS 0.23177f
C4051 FE_E_N.n24 VSS 0.77059f
C4052 FE_E_N.n25 VSS 5.71862f
C4053 FE_E_P.n0 VSS 0.03022f
C4054 FE_E_P.n1 VSS 0.10438f
C4055 FE_E_P.n2 VSS 0.05159f
C4056 FE_E_P.n3 VSS 0.0553f
C4057 FE_E_P.n4 VSS 0.0553f
C4058 FE_E_P.n5 VSS 0.10438f
C4059 FE_E_P.n6 VSS 0.05159f
C4060 FE_E_P.n7 VSS 0.0553f
C4061 FE_E_P.n8 VSS 0.0553f
C4062 FE_E_P.n9 VSS 0.0553f
C4063 FE_E_P.n10 VSS 0.0553f
C4064 FE_E_P.n11 VSS 0.03022f
C4065 FE_E_P.n12 VSS 0.1972f
C4066 FE_E_P.n13 VSS 0.05086f
C4067 FE_E_P.n14 VSS 0.0553f
C4068 FE_E_P.n15 VSS 0.0553f
C4069 FE_E_P.n16 VSS 0.05086f
C4070 FE_E_P.n17 VSS 0.15231f
C4071 FE_E_P.n18 VSS 5.78388f
C4072 FE_E_P.t3 VSS 0.52362f
C4073 FE_E_P.t1 VSS 0.52773f
C4074 FE_E_P.t4 VSS 0.18646f
C4075 FE_E_P.t0 VSS 0.18646f
C4076 FE_E_P.n19 VSS 0.32445f
C4077 FE_E_P.n20 VSS 0.1644f
C4078 FE_E_P.n21 VSS 0.24604f
C4079 FE_E_P.t5 VSS 0.52802f
C4080 FE_E_P.t6 VSS 0.18646f
C4081 FE_E_P.t2 VSS 0.18646f
C4082 FE_E_P.n22 VSS 0.32705f
C4083 FE_E_P.n23 VSS 0.28292f
C4084 FE_E_P.n24 VSS 0.75447f
C4085 FE_O_P.n0 VSS 0.02745f
C4086 FE_O_P.n1 VSS 0.09482f
C4087 FE_O_P.n2 VSS 0.04687f
C4088 FE_O_P.n3 VSS 0.05024f
C4089 FE_O_P.n4 VSS 0.05024f
C4090 FE_O_P.n5 VSS 0.09482f
C4091 FE_O_P.n6 VSS 0.04687f
C4092 FE_O_P.n7 VSS 0.05024f
C4093 FE_O_P.n8 VSS 0.05024f
C4094 FE_O_P.n9 VSS 0.05024f
C4095 FE_O_P.n10 VSS 0.05024f
C4096 FE_O_P.n11 VSS 0.02745f
C4097 FE_O_P.n12 VSS 0.17914f
C4098 FE_O_P.n13 VSS 0.0462f
C4099 FE_O_P.n14 VSS 0.05024f
C4100 FE_O_P.n15 VSS 0.05024f
C4101 FE_O_P.n16 VSS 0.0462f
C4102 FE_O_P.n17 VSS 0.13836f
C4103 FE_O_P.n18 VSS 5.07316f
C4104 FE_O_P.t6 VSS 0.17377f
C4105 FE_O_P.t0 VSS 0.17377f
C4106 FE_O_P.n19 VSS 0.29709f
C4107 FE_O_P.t1 VSS 0.48413f
C4108 FE_O_P.n20 VSS 0.27745f
C4109 FE_O_P.t5 VSS 0.48387f
C4110 FE_O_P.t2 VSS 0.17377f
C4111 FE_O_P.t3 VSS 0.17377f
C4112 FE_O_P.n21 VSS 0.29473f
C4113 FE_O_P.n22 VSS 0.14934f
C4114 FE_O_P.t4 VSS 0.48004f
C4115 FE_O_P.n23 VSS 0.20313f
C4116 FE_O_P.n24 VSS 0.67576f
C4117 FE_O_N.n0 VSS 0.02946f
C4118 FE_O_N.n1 VSS 0.10177f
C4119 FE_O_N.n2 VSS 0.0503f
C4120 FE_O_N.n3 VSS 0.05392f
C4121 FE_O_N.n4 VSS 0.05392f
C4122 FE_O_N.n5 VSS 0.10177f
C4123 FE_O_N.n6 VSS 0.0503f
C4124 FE_O_N.n7 VSS 0.05392f
C4125 FE_O_N.n8 VSS 0.05392f
C4126 FE_O_N.n9 VSS 0.05392f
C4127 FE_O_N.n10 VSS 0.05392f
C4128 FE_O_N.n11 VSS 0.02946f
C4129 FE_O_N.n12 VSS 0.19226f
C4130 FE_O_N.n13 VSS 0.04959f
C4131 FE_O_N.n14 VSS 0.05392f
C4132 FE_O_N.n15 VSS 0.05392f
C4133 FE_O_N.n16 VSS 0.04959f
C4134 FE_O_N.n17 VSS 0.14849f
C4135 FE_O_N.n18 VSS 5.49952f
C4136 FE_O_N.t3 VSS 0.51765f
C4137 FE_O_N.t4 VSS 0.18488f
C4138 FE_O_N.t0 VSS 0.18488f
C4139 FE_O_N.n19 VSS 0.31632f
C4140 FE_O_N.n20 VSS 0.16028f
C4141 FE_O_N.t1 VSS 0.51358f
C4142 FE_O_N.n21 VSS 0.23987f
C4143 FE_O_N.t2 VSS 0.18488f
C4144 FE_O_N.t5 VSS 0.18488f
C4145 FE_O_N.n22 VSS 0.31885f
C4146 FE_O_N.t6 VSS 0.51794f
C4147 FE_O_N.n23 VSS 0.27583f
C4148 FE_O_N.n24 VSS 0.73513f
C4149 FE_O_N.n25 VSS 5.26993f
C4150 E_CAPTURE_CLK.n0 VSS 0.03713f
C4151 E_CAPTURE_CLK.n1 VSS 0.02544f
C4152 E_CAPTURE_CLK.n2 VSS 0.02544f
C4153 E_CAPTURE_CLK.n3 VSS 0.02544f
C4154 E_CAPTURE_CLK.n4 VSS 0.07403f
C4155 E_CAPTURE_CLK.n5 VSS 0.03659f
C4156 E_CAPTURE_CLK.n6 VSS 0.03923f
C4157 E_CAPTURE_CLK.n7 VSS 0.03923f
C4158 E_CAPTURE_CLK.n8 VSS 0.03923f
C4159 E_CAPTURE_CLK.n9 VSS 0.03923f
C4160 E_CAPTURE_CLK.n10 VSS 0.03923f
C4161 E_CAPTURE_CLK.n11 VSS 0.03923f
C4162 E_CAPTURE_CLK.n12 VSS 0.02143f
C4163 E_CAPTURE_CLK.n13 VSS 0.17382f
C4164 E_CAPTURE_CLK.n14 VSS 0.03607f
C4165 E_CAPTURE_CLK.n15 VSS 0.02544f
C4166 E_CAPTURE_CLK.n16 VSS 0.03923f
C4167 E_CAPTURE_CLK.n17 VSS 0.03923f
C4168 E_CAPTURE_CLK.n18 VSS 0.03659f
C4169 E_CAPTURE_CLK.n19 VSS 0.07403f
C4170 E_CAPTURE_CLK.n20 VSS 0.02544f
C4171 E_CAPTURE_CLK.n21 VSS 0.03923f
C4172 E_CAPTURE_CLK.n22 VSS 0.03923f
C4173 E_CAPTURE_CLK.n23 VSS 0.03923f
C4174 E_CAPTURE_CLK.n24 VSS 0.03923f
C4175 E_CAPTURE_CLK.n25 VSS 0.02143f
C4176 E_CAPTURE_CLK.n26 VSS 0.07146f
C4177 E_CAPTURE_CLK.n27 VSS 1.63318f
C4178 O_CAPTURE_CLK.n0 VSS 0.03888f
C4179 O_CAPTURE_CLK.n1 VSS 0.02663f
C4180 O_CAPTURE_CLK.n2 VSS 0.02663f
C4181 O_CAPTURE_CLK.n3 VSS 0.02663f
C4182 O_CAPTURE_CLK.n4 VSS 0.07752f
C4183 O_CAPTURE_CLK.n5 VSS 0.03832f
C4184 O_CAPTURE_CLK.n6 VSS 0.04107f
C4185 O_CAPTURE_CLK.n7 VSS 0.04107f
C4186 O_CAPTURE_CLK.n8 VSS 0.04107f
C4187 O_CAPTURE_CLK.n9 VSS 0.04107f
C4188 O_CAPTURE_CLK.n10 VSS 0.04107f
C4189 O_CAPTURE_CLK.n11 VSS 0.04107f
C4190 O_CAPTURE_CLK.n12 VSS 0.02244f
C4191 O_CAPTURE_CLK.n13 VSS 0.23957f
C4192 O_CAPTURE_CLK.n14 VSS 0.03777f
C4193 O_CAPTURE_CLK.n15 VSS 0.02663f
C4194 O_CAPTURE_CLK.n16 VSS 0.04107f
C4195 O_CAPTURE_CLK.n17 VSS 0.04107f
C4196 O_CAPTURE_CLK.n18 VSS 0.03832f
C4197 O_CAPTURE_CLK.n19 VSS 0.07752f
C4198 O_CAPTURE_CLK.n20 VSS 0.02663f
C4199 O_CAPTURE_CLK.n21 VSS 0.04107f
C4200 O_CAPTURE_CLK.n22 VSS 0.04107f
C4201 O_CAPTURE_CLK.n23 VSS 0.04107f
C4202 O_CAPTURE_CLK.n24 VSS 0.04107f
C4203 O_CAPTURE_CLK.n25 VSS 0.02244f
C4204 O_CAPTURE_CLK.n26 VSS 0.12617f
C4205 O_CAPTURE_CLK.n27 VSS 1.83757f
C4206 E_SENSE_CLK.n0 VSS 0.48295f
C4207 E_SENSE_CLK.n1 VSS 0.08683f
C4208 E_SENSE_CLK.n2 VSS 0.08683f
C4209 E_SENSE_CLK.n3 VSS 0.08683f
C4210 E_SENSE_CLK.n4 VSS 0.08683f
C4211 E_SENSE_CLK.n5 VSS 0.08683f
C4212 E_SENSE_CLK.n6 VSS 0.08683f
C4213 E_SENSE_CLK.n7 VSS 0.25274f
C4214 E_SENSE_CLK.n8 VSS 0.18767f
C4215 E_SENSE_CLK.n9 VSS 0.18767f
C4216 E_SENSE_CLK.n10 VSS 0.18767f
C4217 E_SENSE_CLK.n11 VSS 0.18767f
C4218 E_SENSE_CLK.n12 VSS 0.18767f
C4219 E_SENSE_CLK.n13 VSS 0.18767f
C4220 E_SENSE_CLK.n14 VSS 0.18767f
C4221 E_SENSE_CLK.n15 VSS 0.37076f
C4222 E_SENSE_CLK.n16 VSS 0.12492f
C4223 E_SENSE_CLK.n17 VSS 0.13391f
C4224 E_SENSE_CLK.n18 VSS 0.13391f
C4225 E_SENSE_CLK.n19 VSS 0.13391f
C4226 E_SENSE_CLK.n20 VSS 0.13391f
C4227 E_SENSE_CLK.n21 VSS 0.13391f
C4228 E_SENSE_CLK.n22 VSS 0.13391f
C4229 E_SENSE_CLK.n23 VSS 0.13391f
C4230 E_SENSE_CLK.n24 VSS 0.13391f
C4231 E_SENSE_CLK.n25 VSS 0.12656f
C4232 E_SENSE_CLK.n26 VSS 0.32368f
C4233 E_SENSE_CLK.n27 VSS 3.59662f
C4234 E_SENSE_CLK.n28 VSS 0.245f
C4235 E_SENSE_CLK.n29 VSS 0.12492f
C4236 E_SENSE_CLK.n30 VSS 0.13391f
C4237 E_SENSE_CLK.n31 VSS 0.13391f
C4238 E_SENSE_CLK.n32 VSS 0.12664f
C4239 E_SENSE_CLK.n33 VSS 1.71469f
C4240 E_SENSE_CLK.n34 VSS 5.33963f
C4241 E_SENSE_CLK.n35 VSS 0.46361f
C4242 E_SENSE_CLK.n36 VSS 0.08664f
C4243 E_SENSE_CLK.n37 VSS 0.13391f
C4244 E_SENSE_CLK.n38 VSS 0.18767f
C4245 E_SENSE_CLK.n39 VSS 0.08683f
C4246 E_SENSE_CLK.n40 VSS 0.08683f
C4247 E_SENSE_CLK.n41 VSS 0.25274f
C4248 E_SENSE_CLK.n42 VSS 0.37076f
C4249 E_SENSE_CLK.n43 VSS 0.12492f
C4250 E_SENSE_CLK.n44 VSS 0.13391f
C4251 E_SENSE_CLK.n45 VSS 0.13391f
C4252 E_SENSE_CLK.n46 VSS 0.13391f
C4253 E_SENSE_CLK.n47 VSS 0.18767f
C4254 E_SENSE_CLK.n48 VSS 0.18767f
C4255 E_SENSE_CLK.n49 VSS 0.18747f
C4256 E_SENSE_CLK.n50 VSS 0.13391f
C4257 E_SENSE_CLK.n51 VSS 0.13391f
C4258 E_SENSE_CLK.n52 VSS 0.12205f
C4259 E_SENSE_CLK.n53 VSS 0.20241f
C4260 E_SENSE_CLK.n54 VSS 3.09376f
C4261 E_SENSE_CLK.n55 VSS 2.11991f
C4262 E_SENSE_CLK.n56 VSS 0.14746f
C4263 E_SENSE_CLK.n57 VSS 0.25177f
C4264 E_SENSE_CLK.n58 VSS 0.14579f
C4265 E_SENSE_CLK.n59 VSS 0.1545f
C4266 E_SENSE_CLK.n60 VSS 0.1545f
C4267 E_SENSE_CLK.n61 VSS 0.1545f
C4268 E_SENSE_CLK.n62 VSS 0.06792f
C4269 E_SENSE_CLK.n63 VSS 0.28769f
C4270 E_SENSE_CLK.n64 VSS 0.92908f
C4271 E_SENSE_CLK.n65 VSS 0.245f
C4272 E_SENSE_CLK.n66 VSS 0.12492f
C4273 E_SENSE_CLK.n67 VSS 0.13391f
C4274 E_SENSE_CLK.n68 VSS 0.13391f
C4275 E_SENSE_CLK.n69 VSS 0.12664f
C4276 E_SENSE_CLK.n70 VSS 1.71469f
C4277 E_SENSE_CLK.n71 VSS 3.58162f
C4278 E_SENSE_CLK.n72 VSS 0.39864f
C4279 E_SENSE_CLK.n73 VSS 0.08683f
C4280 E_SENSE_CLK.n74 VSS 0.13391f
C4281 E_SENSE_CLK.n75 VSS 0.18767f
C4282 E_SENSE_CLK.n76 VSS 0.13391f
C4283 E_SENSE_CLK.n77 VSS 0.08683f
C4284 E_SENSE_CLK.n78 VSS 0.08683f
C4285 E_SENSE_CLK.n79 VSS 0.13391f
C4286 E_SENSE_CLK.n80 VSS 0.37076f
C4287 E_SENSE_CLK.n81 VSS 0.13391f
C4288 E_SENSE_CLK.n82 VSS 0.12492f
C4289 E_SENSE_CLK.n83 VSS 0.25274f
C4290 E_SENSE_CLK.n84 VSS 0.13391f
C4291 E_SENSE_CLK.n85 VSS 0.18767f
C4292 E_SENSE_CLK.n86 VSS 0.18767f
C4293 E_SENSE_CLK.n87 VSS 0.18767f
C4294 E_SENSE_CLK.n88 VSS 0.13391f
C4295 E_SENSE_CLK.n89 VSS 0.08683f
C4296 E_SENSE_CLK.n90 VSS 0.08683f
C4297 E_SENSE_CLK.n91 VSS 0.08683f
C4298 E_SENSE_CLK.n92 VSS 0.13391f
C4299 E_SENSE_CLK.n93 VSS 0.18767f
C4300 E_SENSE_CLK.n94 VSS 0.18767f
C4301 E_SENSE_CLK.n95 VSS 0.18767f
C4302 E_SENSE_CLK.n96 VSS 0.13391f
C4303 E_SENSE_CLK.n97 VSS 0.12656f
C4304 E_SENSE_CLK.n98 VSS 0.23919f
C4305 E_SENSE_CLK.n99 VSS 3.09997f
C4306 E_SENSE_CLK.n100 VSS 4.36312f
C4307 O_SENSE_CLK.n0 VSS 0.48295f
C4308 O_SENSE_CLK.n1 VSS 0.08683f
C4309 O_SENSE_CLK.n2 VSS 0.13391f
C4310 O_SENSE_CLK.n3 VSS 0.18767f
C4311 O_SENSE_CLK.n4 VSS 0.13391f
C4312 O_SENSE_CLK.n5 VSS 0.08683f
C4313 O_SENSE_CLK.n6 VSS 0.08683f
C4314 O_SENSE_CLK.n7 VSS 0.13391f
C4315 O_SENSE_CLK.n8 VSS 0.37076f
C4316 O_SENSE_CLK.n9 VSS 0.13391f
C4317 O_SENSE_CLK.n10 VSS 0.12492f
C4318 O_SENSE_CLK.n11 VSS 0.25274f
C4319 O_SENSE_CLK.n12 VSS 0.13391f
C4320 O_SENSE_CLK.n13 VSS 0.18767f
C4321 O_SENSE_CLK.n14 VSS 0.18767f
C4322 O_SENSE_CLK.n15 VSS 0.18767f
C4323 O_SENSE_CLK.n16 VSS 0.13391f
C4324 O_SENSE_CLK.n17 VSS 0.08683f
C4325 O_SENSE_CLK.n18 VSS 0.08683f
C4326 O_SENSE_CLK.n19 VSS 0.08683f
C4327 O_SENSE_CLK.n20 VSS 0.13391f
C4328 O_SENSE_CLK.n21 VSS 0.18767f
C4329 O_SENSE_CLK.n22 VSS 0.18767f
C4330 O_SENSE_CLK.n23 VSS 0.18767f
C4331 O_SENSE_CLK.n24 VSS 0.13391f
C4332 O_SENSE_CLK.n25 VSS 0.12656f
C4333 O_SENSE_CLK.n26 VSS 0.32368f
C4334 O_SENSE_CLK.n27 VSS 3.59662f
C4335 O_SENSE_CLK.n28 VSS 0.12664f
C4336 O_SENSE_CLK.n29 VSS 0.12492f
C4337 O_SENSE_CLK.n30 VSS 0.13391f
C4338 O_SENSE_CLK.n31 VSS 0.13391f
C4339 O_SENSE_CLK.n32 VSS 0.245f
C4340 O_SENSE_CLK.n33 VSS 1.71469f
C4341 O_SENSE_CLK.n34 VSS 5.33963f
C4342 O_SENSE_CLK.n35 VSS 0.46361f
C4343 O_SENSE_CLK.n36 VSS 0.12205f
C4344 O_SENSE_CLK.n37 VSS 0.08683f
C4345 O_SENSE_CLK.n38 VSS 0.13391f
C4346 O_SENSE_CLK.n39 VSS 0.08683f
C4347 O_SENSE_CLK.n40 VSS 0.13391f
C4348 O_SENSE_CLK.n41 VSS 0.18747f
C4349 O_SENSE_CLK.n42 VSS 0.18767f
C4350 O_SENSE_CLK.n43 VSS 0.18767f
C4351 O_SENSE_CLK.n44 VSS 0.18767f
C4352 O_SENSE_CLK.n45 VSS 0.37076f
C4353 O_SENSE_CLK.n46 VSS 0.12492f
C4354 O_SENSE_CLK.n47 VSS 0.25274f
C4355 O_SENSE_CLK.n48 VSS 0.13391f
C4356 O_SENSE_CLK.n49 VSS 0.13391f
C4357 O_SENSE_CLK.n50 VSS 0.13391f
C4358 O_SENSE_CLK.n51 VSS 0.13391f
C4359 O_SENSE_CLK.n52 VSS 0.08664f
C4360 O_SENSE_CLK.n53 VSS 0.20241f
C4361 O_SENSE_CLK.n54 VSS 3.09376f
C4362 O_SENSE_CLK.n55 VSS 2.11991f
C4363 O_SENSE_CLK.n56 VSS 0.06792f
C4364 O_SENSE_CLK.n57 VSS 0.1545f
C4365 O_SENSE_CLK.n58 VSS 0.14579f
C4366 O_SENSE_CLK.n59 VSS 0.25177f
C4367 O_SENSE_CLK.n60 VSS 0.1545f
C4368 O_SENSE_CLK.n61 VSS 0.1545f
C4369 O_SENSE_CLK.n62 VSS 0.14746f
C4370 O_SENSE_CLK.n63 VSS 0.28769f
C4371 O_SENSE_CLK.n64 VSS 0.92908f
C4372 O_SENSE_CLK.n65 VSS 0.12664f
C4373 O_SENSE_CLK.n66 VSS 0.12492f
C4374 O_SENSE_CLK.n67 VSS 0.13391f
C4375 O_SENSE_CLK.n68 VSS 0.13391f
C4376 O_SENSE_CLK.n69 VSS 0.245f
C4377 O_SENSE_CLK.n70 VSS 1.71469f
C4378 O_SENSE_CLK.n71 VSS 3.58161f
C4379 O_SENSE_CLK.n72 VSS 0.39864f
C4380 O_SENSE_CLK.n73 VSS 0.08683f
C4381 O_SENSE_CLK.n74 VSS 0.08683f
C4382 O_SENSE_CLK.n75 VSS 0.08683f
C4383 O_SENSE_CLK.n76 VSS 0.08683f
C4384 O_SENSE_CLK.n77 VSS 0.08683f
C4385 O_SENSE_CLK.n78 VSS 0.08683f
C4386 O_SENSE_CLK.n79 VSS 0.25274f
C4387 O_SENSE_CLK.n80 VSS 0.18767f
C4388 O_SENSE_CLK.n81 VSS 0.18767f
C4389 O_SENSE_CLK.n82 VSS 0.18767f
C4390 O_SENSE_CLK.n83 VSS 0.18767f
C4391 O_SENSE_CLK.n84 VSS 0.18767f
C4392 O_SENSE_CLK.n85 VSS 0.18767f
C4393 O_SENSE_CLK.n86 VSS 0.18767f
C4394 O_SENSE_CLK.n87 VSS 0.37076f
C4395 O_SENSE_CLK.n88 VSS 0.12492f
C4396 O_SENSE_CLK.n89 VSS 0.13391f
C4397 O_SENSE_CLK.n90 VSS 0.13391f
C4398 O_SENSE_CLK.n91 VSS 0.13391f
C4399 O_SENSE_CLK.n92 VSS 0.13391f
C4400 O_SENSE_CLK.n93 VSS 0.13391f
C4401 O_SENSE_CLK.n94 VSS 0.13391f
C4402 O_SENSE_CLK.n95 VSS 0.13391f
C4403 O_SENSE_CLK.n96 VSS 0.13391f
C4404 O_SENSE_CLK.n97 VSS 0.12656f
C4405 O_SENSE_CLK.n98 VSS 0.23919f
C4406 O_SENSE_CLK.n99 VSS 3.09997f
C4407 O_SENSE_CLK.n100 VSS 4.36312f
C4408 SAMP_E_P.t2 VSS 0.17572f
C4409 SAMP_E_P.n0 VSS 0.48734f
C4410 SAMP_E_P.n1 VSS 1.17866f
C4411 SAMP_E_P.n2 VSS 0.11568f
C4412 SAMP_E_P.t1 VSS 0.41942f
C4413 SAMP_E_P.n3 VSS 0.11851f
C4414 SAMP_E_P.t0 VSS 0.41942f
C4415 SAMP_E_P.n4 VSS 0.11851f
C4416 SAMP_E_P.n5 VSS 0.10075f
C4417 SAMP_E_P.n6 VSS 0.37014f
C4418 SAMP_E_P.t3 VSS 0.40606f
C4419 SAMP_E_P.t4 VSS 0.40595f
C4420 SAMP_E_P.n7 VSS 0.27418f
C4421 SAMP_E_P.n8 VSS 0.87007f
C4422 SAMP_E_P.n9 VSS 2.26493f
C4423 SAMP_E_P.n10 VSS 0.29542f
C4424 SAMP_E_P.n11 VSS 0.07777f
C4425 SAMP_E_P.n12 VSS 0.05533f
C4426 SAMP_E_P.n13 VSS 0.08533f
C4427 SAMP_E_P.n14 VSS 0.08533f
C4428 SAMP_E_P.n15 VSS 0.11959f
C4429 SAMP_E_P.n16 VSS 0.05533f
C4430 SAMP_E_P.n17 VSS 0.16105f
C4431 SAMP_E_P.n18 VSS 0.23625f
C4432 SAMP_E_P.n19 VSS 0.0796f
C4433 SAMP_E_P.n20 VSS 0.08533f
C4434 SAMP_E_P.n21 VSS 0.08533f
C4435 SAMP_E_P.n22 VSS 0.08533f
C4436 SAMP_E_P.n23 VSS 0.11959f
C4437 SAMP_E_P.n24 VSS 0.11959f
C4438 SAMP_E_P.n25 VSS 0.11946f
C4439 SAMP_E_P.n26 VSS 0.08533f
C4440 SAMP_E_P.n27 VSS 0.05521f
C4441 SAMP_E_P.n28 VSS 0.12898f
C4442 SAMP_E_P.n29 VSS 4.34112f
C4443 SAMP_E_P.n30 VSS 9.51019f
C4444 SAMP_E_N.t4 VSS 0.15427f
C4445 SAMP_E_N.t2 VSS 0.36253f
C4446 SAMP_E_N.t3 VSS 0.36263f
C4447 SAMP_E_N.n0 VSS 0.24071f
C4448 SAMP_E_N.n1 VSS 0.30629f
C4449 SAMP_E_N.n2 VSS 1.02234f
C4450 SAMP_E_N.n3 VSS 0.07402f
C4451 SAMP_E_N.t0 VSS 0.38309f
C4452 SAMP_E_N.t1 VSS 0.38309f
C4453 SAMP_E_N.n4 VSS 0.10404f
C4454 SAMP_E_N.n5 VSS 0.10404f
C4455 SAMP_E_N.n6 VSS 0.08845f
C4456 SAMP_E_N.n7 VSS 0.32495f
C4457 SAMP_E_N.n8 VSS 0.76386f
C4458 SAMP_E_N.n9 VSS 2.00335f
C4459 SAMP_E_N.n10 VSS 0.25936f
C4460 SAMP_E_N.n11 VSS 0.04847f
C4461 SAMP_E_N.n12 VSS 0.07491f
C4462 SAMP_E_N.n13 VSS 0.10499f
C4463 SAMP_E_N.n14 VSS 0.04858f
C4464 SAMP_E_N.n15 VSS 0.04858f
C4465 SAMP_E_N.n16 VSS 0.14139f
C4466 SAMP_E_N.n17 VSS 0.20741f
C4467 SAMP_E_N.n18 VSS 0.06989f
C4468 SAMP_E_N.n19 VSS 0.07491f
C4469 SAMP_E_N.n20 VSS 0.07491f
C4470 SAMP_E_N.n21 VSS 0.07491f
C4471 SAMP_E_N.n22 VSS 0.10499f
C4472 SAMP_E_N.n23 VSS 0.10499f
C4473 SAMP_E_N.n24 VSS 0.10488f
C4474 SAMP_E_N.n25 VSS 0.07491f
C4475 SAMP_E_N.n26 VSS 0.07491f
C4476 SAMP_E_N.n27 VSS 0.06828f
C4477 SAMP_E_N.n28 VSS 0.11323f
C4478 SAMP_E_N.n29 VSS 2.86652f
C4479 E_SENSE_BOOST.n0 VSS 0.1262f
C4480 E_SENSE_BOOST.n1 VSS 0.04224f
C4481 E_SENSE_BOOST.n2 VSS 0.07532f
C4482 E_SENSE_BOOST.n3 VSS 0.10175f
C4483 E_SENSE_BOOST.n4 VSS 0.04234f
C4484 E_SENSE_BOOST.n5 VSS 0.04234f
C4485 E_SENSE_BOOST.n6 VSS 0.04234f
C4486 E_SENSE_BOOST.n7 VSS 0.04234f
C4487 E_SENSE_BOOST.n8 VSS 0.04234f
C4488 E_SENSE_BOOST.n9 VSS 0.12322f
C4489 E_SENSE_BOOST.n10 VSS 0.10175f
C4490 E_SENSE_BOOST.n11 VSS 0.10175f
C4491 E_SENSE_BOOST.n12 VSS 0.10175f
C4492 E_SENSE_BOOST.n13 VSS 0.20127f
C4493 E_SENSE_BOOST.n14 VSS 0.07108f
C4494 E_SENSE_BOOST.n15 VSS 0.07532f
C4495 E_SENSE_BOOST.n16 VSS 0.07532f
C4496 E_SENSE_BOOST.n17 VSS 0.07532f
C4497 E_SENSE_BOOST.n18 VSS 0.07532f
C4498 E_SENSE_BOOST.n19 VSS 0.07532f
C4499 E_SENSE_BOOST.n20 VSS 0.07532f
C4500 E_SENSE_BOOST.n21 VSS 0.10175f
C4501 E_SENSE_BOOST.n22 VSS 0.10175f
C4502 E_SENSE_BOOST.n23 VSS 0.10165f
C4503 E_SENSE_BOOST.n24 VSS 0.07532f
C4504 E_SENSE_BOOST.n25 VSS 0.07532f
C4505 E_SENSE_BOOST.n26 VSS 0.04234f
C4506 E_SENSE_BOOST.n27 VSS 0.07532f
C4507 E_SENSE_BOOST.n28 VSS 0.10175f
C4508 E_SENSE_BOOST.n29 VSS 0.04234f
C4509 E_SENSE_BOOST.n30 VSS 0.04234f
C4510 E_SENSE_BOOST.n31 VSS 0.04234f
C4511 E_SENSE_BOOST.n32 VSS 0.04234f
C4512 E_SENSE_BOOST.n33 VSS 0.04234f
C4513 E_SENSE_BOOST.n34 VSS 0.04234f
C4514 E_SENSE_BOOST.n35 VSS 0.04234f
C4515 E_SENSE_BOOST.n36 VSS 0.04234f
C4516 E_SENSE_BOOST.n37 VSS 0.04234f
C4517 E_SENSE_BOOST.n38 VSS 0.12322f
C4518 E_SENSE_BOOST.n39 VSS 0.10175f
C4519 E_SENSE_BOOST.n40 VSS 0.10175f
C4520 E_SENSE_BOOST.n41 VSS 0.10175f
C4521 E_SENSE_BOOST.n42 VSS 0.10175f
C4522 E_SENSE_BOOST.n43 VSS 0.10175f
C4523 E_SENSE_BOOST.n44 VSS 0.10175f
C4524 E_SENSE_BOOST.n45 VSS 0.10175f
C4525 E_SENSE_BOOST.n46 VSS 0.10175f
C4526 E_SENSE_BOOST.n47 VSS 0.20127f
C4527 E_SENSE_BOOST.n48 VSS 0.07108f
C4528 E_SENSE_BOOST.n49 VSS 0.07532f
C4529 E_SENSE_BOOST.n50 VSS 0.07532f
C4530 E_SENSE_BOOST.n51 VSS 0.07532f
C4531 E_SENSE_BOOST.n52 VSS 0.07532f
C4532 E_SENSE_BOOST.n53 VSS 0.07532f
C4533 E_SENSE_BOOST.n54 VSS 0.07532f
C4534 E_SENSE_BOOST.n55 VSS 0.07532f
C4535 E_SENSE_BOOST.n56 VSS 0.07532f
C4536 E_SENSE_BOOST.n57 VSS 0.07532f
C4537 E_SENSE_BOOST.n58 VSS 0.07532f
C4538 E_SENSE_BOOST.n59 VSS 0.07532f
C4539 E_SENSE_BOOST.n60 VSS 0.10175f
C4540 E_SENSE_BOOST.n61 VSS 0.10175f
C4541 E_SENSE_BOOST.n62 VSS 0.10165f
C4542 E_SENSE_BOOST.n63 VSS 0.07532f
C4543 E_SENSE_BOOST.n64 VSS 0.04224f
C4544 E_SENSE_BOOST.n65 VSS 0.07629f
C4545 E_SENSE_BOOST.n66 VSS 2.29891f
C4546 SAMP_O_P.t0 VSS 0.15413f
C4547 SAMP_O_P.n0 VSS 0.39879f
C4548 SAMP_O_P.n1 VSS 1.10978f
C4549 SAMP_O_P.n2 VSS 0.07396f
C4550 SAMP_O_P.t1 VSS 0.38286f
C4551 SAMP_O_P.n3 VSS 0.10395f
C4552 SAMP_O_P.t2 VSS 0.38286f
C4553 SAMP_O_P.n4 VSS 0.10395f
C4554 SAMP_O_P.n5 VSS 0.08838f
C4555 SAMP_O_P.n6 VSS 0.32466f
C4556 SAMP_O_P.t4 VSS 0.3613f
C4557 SAMP_O_P.t3 VSS 0.36119f
C4558 SAMP_O_P.n7 VSS 0.2405f
C4559 SAMP_O_P.n8 VSS 0.76319f
C4560 SAMP_O_P.n9 VSS 2.00158f
C4561 SAMP_O_P.n10 VSS 0.25913f
C4562 SAMP_O_P.n11 VSS 0.06822f
C4563 SAMP_O_P.n12 VSS 0.04854f
C4564 SAMP_O_P.n13 VSS 0.07485f
C4565 SAMP_O_P.n14 VSS 0.07485f
C4566 SAMP_O_P.n15 VSS 0.1049f
C4567 SAMP_O_P.n16 VSS 0.04854f
C4568 SAMP_O_P.n17 VSS 0.14127f
C4569 SAMP_O_P.n18 VSS 0.20723f
C4570 SAMP_O_P.n19 VSS 0.06983f
C4571 SAMP_O_P.n20 VSS 0.07485f
C4572 SAMP_O_P.n21 VSS 0.07485f
C4573 SAMP_O_P.n22 VSS 0.07485f
C4574 SAMP_O_P.n23 VSS 0.1049f
C4575 SAMP_O_P.n24 VSS 0.1049f
C4576 SAMP_O_P.n25 VSS 0.10479f
C4577 SAMP_O_P.n26 VSS 0.07485f
C4578 SAMP_O_P.n27 VSS 0.04843f
C4579 SAMP_O_P.n28 VSS 0.11313f
C4580 SAMP_O_P.n29 VSS 2.86399f
C4581 SAMP_O_N.t1 VSS 0.17586f
C4582 SAMP_O_N.t4 VSS 0.4073f
C4583 SAMP_O_N.t3 VSS 0.40742f
C4584 SAMP_O_N.n0 VSS 0.27441f
C4585 SAMP_O_N.n1 VSS 0.37031f
C4586 SAMP_O_N.n2 VSS 1.0904f
C4587 SAMP_O_N.n3 VSS 0.11578f
C4588 SAMP_O_N.t0 VSS 0.41967f
C4589 SAMP_O_N.t2 VSS 0.41967f
C4590 SAMP_O_N.n4 VSS 0.11861f
C4591 SAMP_O_N.n5 VSS 0.11861f
C4592 SAMP_O_N.n6 VSS 0.10084f
C4593 SAMP_O_N.n7 VSS 0.37044f
C4594 SAMP_O_N.n8 VSS 0.87078f
C4595 SAMP_O_N.n9 VSS 2.26678f
C4596 SAMP_O_N.n10 VSS 0.29566f
C4597 SAMP_O_N.n11 VSS 0.05525f
C4598 SAMP_O_N.n12 VSS 0.0854f
C4599 SAMP_O_N.n13 VSS 0.11969f
C4600 SAMP_O_N.n14 VSS 0.05538f
C4601 SAMP_O_N.n15 VSS 0.05538f
C4602 SAMP_O_N.n16 VSS 0.16118f
C4603 SAMP_O_N.n17 VSS 0.23645f
C4604 SAMP_O_N.n18 VSS 0.07967f
C4605 SAMP_O_N.n19 VSS 0.0854f
C4606 SAMP_O_N.n20 VSS 0.0854f
C4607 SAMP_O_N.n21 VSS 0.0854f
C4608 SAMP_O_N.n22 VSS 0.11969f
C4609 SAMP_O_N.n23 VSS 0.11969f
C4610 SAMP_O_N.n24 VSS 0.11956f
C4611 SAMP_O_N.n25 VSS 0.0854f
C4612 SAMP_O_N.n26 VSS 0.0854f
C4613 SAMP_O_N.n27 VSS 0.07784f
C4614 SAMP_O_N.n28 VSS 0.12908f
C4615 SAMP_O_N.n29 VSS 4.34466f
C4616 SAMP_O_N.n30 VSS 9.51795f
C4617 O_SENSE_BOOST.n0 VSS 0.1262f
C4618 O_SENSE_BOOST.n1 VSS 0.04224f
C4619 O_SENSE_BOOST.n2 VSS 0.07532f
C4620 O_SENSE_BOOST.n3 VSS 0.10175f
C4621 O_SENSE_BOOST.n4 VSS 0.04234f
C4622 O_SENSE_BOOST.n5 VSS 0.04234f
C4623 O_SENSE_BOOST.n6 VSS 0.04234f
C4624 O_SENSE_BOOST.n7 VSS 0.04234f
C4625 O_SENSE_BOOST.n8 VSS 0.04234f
C4626 O_SENSE_BOOST.n9 VSS 0.04234f
C4627 O_SENSE_BOOST.n10 VSS 0.04234f
C4628 O_SENSE_BOOST.n11 VSS 0.04234f
C4629 O_SENSE_BOOST.n12 VSS 0.04234f
C4630 O_SENSE_BOOST.n13 VSS 0.04234f
C4631 O_SENSE_BOOST.n14 VSS 0.12322f
C4632 O_SENSE_BOOST.n15 VSS 0.10175f
C4633 O_SENSE_BOOST.n16 VSS 0.10175f
C4634 O_SENSE_BOOST.n17 VSS 0.10175f
C4635 O_SENSE_BOOST.n18 VSS 0.10175f
C4636 O_SENSE_BOOST.n19 VSS 0.10175f
C4637 O_SENSE_BOOST.n20 VSS 0.10175f
C4638 O_SENSE_BOOST.n21 VSS 0.10175f
C4639 O_SENSE_BOOST.n22 VSS 0.10175f
C4640 O_SENSE_BOOST.n23 VSS 0.20127f
C4641 O_SENSE_BOOST.n24 VSS 0.07108f
C4642 O_SENSE_BOOST.n25 VSS 0.07532f
C4643 O_SENSE_BOOST.n26 VSS 0.07532f
C4644 O_SENSE_BOOST.n27 VSS 0.07532f
C4645 O_SENSE_BOOST.n28 VSS 0.07532f
C4646 O_SENSE_BOOST.n29 VSS 0.07532f
C4647 O_SENSE_BOOST.n30 VSS 0.07532f
C4648 O_SENSE_BOOST.n31 VSS 0.07532f
C4649 O_SENSE_BOOST.n32 VSS 0.07532f
C4650 O_SENSE_BOOST.n33 VSS 0.07532f
C4651 O_SENSE_BOOST.n34 VSS 0.07532f
C4652 O_SENSE_BOOST.n35 VSS 0.07532f
C4653 O_SENSE_BOOST.n36 VSS 0.10175f
C4654 O_SENSE_BOOST.n37 VSS 0.10175f
C4655 O_SENSE_BOOST.n38 VSS 0.10165f
C4656 O_SENSE_BOOST.n39 VSS 0.07532f
C4657 O_SENSE_BOOST.n40 VSS 0.07532f
C4658 O_SENSE_BOOST.n41 VSS 0.04234f
C4659 O_SENSE_BOOST.n42 VSS 0.07532f
C4660 O_SENSE_BOOST.n43 VSS 0.10175f
C4661 O_SENSE_BOOST.n44 VSS 0.04234f
C4662 O_SENSE_BOOST.n45 VSS 0.04234f
C4663 O_SENSE_BOOST.n46 VSS 0.04234f
C4664 O_SENSE_BOOST.n47 VSS 0.04234f
C4665 O_SENSE_BOOST.n48 VSS 0.12322f
C4666 O_SENSE_BOOST.n49 VSS 0.10175f
C4667 O_SENSE_BOOST.n50 VSS 0.10175f
C4668 O_SENSE_BOOST.n51 VSS 0.10175f
C4669 O_SENSE_BOOST.n52 VSS 0.20127f
C4670 O_SENSE_BOOST.n53 VSS 0.07108f
C4671 O_SENSE_BOOST.n54 VSS 0.07532f
C4672 O_SENSE_BOOST.n55 VSS 0.07532f
C4673 O_SENSE_BOOST.n56 VSS 0.07532f
C4674 O_SENSE_BOOST.n57 VSS 0.07532f
C4675 O_SENSE_BOOST.n58 VSS 0.07532f
C4676 O_SENSE_BOOST.n59 VSS 0.07532f
C4677 O_SENSE_BOOST.n60 VSS 0.10175f
C4678 O_SENSE_BOOST.n61 VSS 0.10175f
C4679 O_SENSE_BOOST.n62 VSS 0.10165f
C4680 O_SENSE_BOOST.n63 VSS 0.07532f
C4681 O_SENSE_BOOST.n64 VSS 0.04224f
C4682 O_SENSE_BOOST.n65 VSS 0.07629f
C4683 O_SENSE_BOOST.n66 VSS 2.29891f
C4684 RX_RESTN.n0 VSS 0.13623f
C4685 RX_RESTN.n1 VSS 0.47066f
C4686 RX_RESTN.n2 VSS 2.92409f
C4687 RX_RESTN.t0 VSS 0.11488f
C4688 RX_RESTN.t1 VSS 0.46315f
C4689 RX_RESTN.t2 VSS 0.46315f
C4690 RX_RESTN.n3 VSS 0.20876f
C4691 RX_RESTN.n4 VSS 1.09392f
C4692 RX_RESTP.n0 VSS 0.46983f
C4693 RX_RESTP.n1 VSS 0.21633f
C4694 RX_RESTP.n2 VSS 3.88442f
C4695 RX_RESTP.t0 VSS 0.11779f
C4696 RX_RESTP.t1 VSS 0.46518f
C4697 RX_RESTP.t2 VSS 0.46518f
C4698 RX_RESTP.n3 VSS 0.21405f
C4699 RX_RESTP.n4 VSS 1.08937f
C4700 PI_CLK_P.n0 VSS 0.07536f
C4701 PI_CLK_P.n1 VSS 0.14482f
C4702 PI_CLK_P.n2 VSS 2.1641f
C4703 PI_CLK_P.t1 VSS 0.21957f
C4704 PI_CLK_P.t2 VSS 0.21957f
C4705 PI_CLK_P.n3 VSS 0.09132f
C4706 PI_CLK_P.t0 VSS 0.04346f
C4707 PI_CLK_P.n4 VSS 8.64166f
C4708 PI_CLK_N.n0 VSS 0.0617f
C4709 PI_CLK_N.n1 VSS 0.1254f
C4710 PI_CLK_N.n2 VSS 1.65367f
C4711 PI_CLK_N.t1 VSS 0.21221f
C4712 PI_CLK_N.t2 VSS 0.21221f
C4713 PI_CLK_N.n3 VSS 0.08342f
C4714 PI_CLK_N.t0 VSS 0.03911f
C4715 PI_CLK_N.n4 VSS 7.48498f
C4716 SAMP_BIAS.n0 VSS 0.02864f
C4717 SAMP_BIAS.n1 VSS 0.03072f
C4718 SAMP_BIAS.n2 VSS 0.03072f
C4719 SAMP_BIAS.n3 VSS 0.02864f
C4720 SAMP_BIAS.n4 VSS 0.25264f
C4721 SAMP_BIAS.n5 VSS 0.02864f
C4722 SAMP_BIAS.n6 VSS 0.03072f
C4723 SAMP_BIAS.n7 VSS 0.03072f
C4724 SAMP_BIAS.n8 VSS 0.02864f
C4725 SAMP_BIAS.n9 VSS 0.08713f
C4726 SAMP_BIAS.n10 VSS 2.16477f
C4727 CLK_REST_BIAS.n0 VSS 0.04295f
C4728 CLK_REST_BIAS.n1 VSS 0.04563f
C4729 CLK_REST_BIAS.n2 VSS 0.04563f
C4730 CLK_REST_BIAS.n3 VSS 0.04295f
C4731 CLK_REST_BIAS.n4 VSS 0.32382f
C4732 CLK_REST_BIAS.n5 VSS 0.04295f
C4733 CLK_REST_BIAS.n6 VSS 0.04563f
C4734 CLK_REST_BIAS.n7 VSS 0.04563f
C4735 CLK_REST_BIAS.n8 VSS 0.04295f
C4736 CLK_REST_BIAS.n9 VSS 0.11419f
C4737 CLK_REST_BIAS.n10 VSS 1.24853f
C4738 REST_BIAS.n0 VSS 0.02944f
C4739 REST_BIAS.n1 VSS 0.03128f
C4740 REST_BIAS.n2 VSS 0.03128f
C4741 REST_BIAS.n3 VSS 0.02944f
C4742 REST_BIAS.n4 VSS 0.22195f
C4743 REST_BIAS.n5 VSS 0.02944f
C4744 REST_BIAS.n6 VSS 0.03128f
C4745 REST_BIAS.n7 VSS 0.03128f
C4746 REST_BIAS.n8 VSS 0.02944f
C4747 REST_BIAS.n9 VSS 0.07827f
C4748 REST_BIAS.n10 VSS 1.38426f
C4749 PI_RAW_P.n0 VSS 0.06074f
C4750 PI_RAW_P.t0 VSS 0.03119f
C4751 PI_RAW_P.t1 VSS 0.08077f
C4752 PI_RAW_P.t2 VSS 0.08079f
C4753 PI_RAW_P.n1 VSS 0.09053f
C4754 PI_RAW_P.n2 VSS 1.79293f
C4755 PI_RAW_P.n3 VSS 1.69797f
C4756 PI_RAW_N.n0 VSS 0.05408f
C4757 PI_RAW_N.t2 VSS 0.02761f
C4758 PI_RAW_N.t0 VSS 0.07926f
C4759 PI_RAW_N.t1 VSS 0.07924f
C4760 PI_RAW_N.n1 VSS 0.08013f
C4761 PI_RAW_N.n2 VSS 1.04721f
C4762 PHASE_A_P.n0 VSS 0.14267f
C4763 PHASE_B_P.n0 VSS 0.23291f
C4764 PHASE_B_N.n0 VSS 0.26623f
C4765 PHASE_A_N.n0 VSS 0.14243f
C4766 PI_BUF_BIAS.n0 VSS 0.02478f
C4767 PI_BUF_BIAS.n1 VSS 0.02659f
C4768 PI_BUF_BIAS.n2 VSS 0.02659f
C4769 PI_BUF_BIAS.n3 VSS 0.02478f
C4770 PI_BUF_BIAS.n4 VSS 0.08576f
C4771 PI_CTRL_A.n0 VSS 0.01893f
C4772 PI_CTRL_A.n1 VSS 0.02131f
C4773 PI_CTRL_A.n2 VSS 0.02131f
C4774 PI_CTRL_A.n3 VSS 0.01893f
C4775 PI_CTRL_A.n4 VSS 0.12577f
C4776 PI_CTRL_B.n0 VSS 0.0114f
C4777 PI_CTRL_B.n1 VSS 0.01283f
C4778 PI_CTRL_B.n2 VSS 0.01283f
C4779 PI_CTRL_B.n3 VSS 0.0114f
C4780 PI_CTRL_B.n4 VSS 0.13262f
C4781 RX_RAWP.n0 VSS 0.50786f
C4782 RX_RAWP.t1 VSS 0.07485f
C4783 RX_RAWP.t0 VSS 0.23743f
C4784 RX_RAWP.t3 VSS 0.18226f
C4785 RX_RAWP.t2 VSS 0.18231f
C4786 RX_RAWP.n1 VSS 0.32417f
C4787 RX_RAWP.n2 VSS 1.0692f
C4788 RX_RAWP.n3 VSS 0.45242f
C4789 RX_RAWN.n0 VSS 0.47865f
C4790 RX_RAWN.t1 VSS 0.07027f
C4791 RX_RAWN.t0 VSS 0.23918f
C4792 RX_RAWN.t3 VSS 0.17321f
C4793 RX_RAWN.t2 VSS 0.17316f
C4794 RX_RAWN.n1 VSS 0.30433f
C4795 RX_RAWN.n2 VSS 1.00377f
C4796 RX_RAWN.n3 VSS 0.42473f
C4797 RX_BW_EN_N.n0 VSS 2.37285f
C4798 RX_BW_EN_N.n1 VSS 1.30569f
C4799 RX_BW_EN_N.n2 VSS 1.47388f
C4800 VTHP.n0 VSS 0.61322f
C4801 VTHN.n0 VSS 0.63951f
C4802 RX_BIAS.n0 VSS 0.02779f
C4803 RX_BIAS.n1 VSS 0.02951f
C4804 RX_BIAS.n2 VSS 0.02951f
C4805 RX_BIAS.n3 VSS 0.02951f
C4806 RX_BIAS.n4 VSS 0.02779f
C4807 RX_BIAS.n5 VSS 0.11903f
C4808 RX_BIAS.n6 VSS 0.01107f
C4809 RX_BIAS.n7 VSS 0.01376f
C4810 RX_BIAS.n8 VSS 0.01376f
C4811 RX_BIAS.n9 VSS 0.01107f
C4812 RX_BIAS.n10 VSS 0.27482f
C4813 RX_BIAS.n11 VSS 0.02779f
C4814 RX_BIAS.n12 VSS 0.02951f
C4815 RX_BIAS.n13 VSS 0.02951f
C4816 RX_BIAS.n14 VSS 0.02951f
C4817 RX_BIAS.n15 VSS 0.02779f
C4818 RX_BIAS.n16 VSS 0.10781f
C4819 RX_BIAS.n17 VSS 0.72566f
C4820 RX_BIAS.n18 VSS 0.71306f
C4821 RXP.t6 VSS 0.17644f
C4822 RXP.n0 VSS 0.53777f
C4823 RXP.n1 VSS 2.23071f
C4824 RXP.t3 VSS 0.03572f
C4825 RXP.t5 VSS 0.03572f
C4826 RXP.t2 VSS 0.03572f
C4827 RXP.t4 VSS 0.03572f
C4828 RXP.t1 VSS 0.03572f
C4829 RXP.t0 VSS 0.03515f
C4830 RXP.t7 VSS 0.05222f
C4831 RXP.n2 VSS 0.77274f
C4832 RXP.n3 VSS 0.46341f
C4833 RXP.n4 VSS 0.46341f
C4834 RXP.n5 VSS 0.46341f
C4835 RXP.n6 VSS 0.46341f
C4836 RXP.n7 VSS 0.42489f
C4837 RXN.t7 VSS 0.07002f
C4838 RXN.n0 VSS 0.21341f
C4839 RXN.n1 VSS 0.88522f
C4840 RXN.t3 VSS 0.01418f
C4841 RXN.t4 VSS 0.01418f
C4842 RXN.t0 VSS 0.01418f
C4843 RXN.t5 VSS 0.01418f
C4844 RXN.t2 VSS 0.01418f
C4845 RXN.t6 VSS 0.01395f
C4846 RXN.t1 VSS 0.02072f
C4847 RXN.n2 VSS 0.30665f
C4848 RXN.n3 VSS 0.1839f
C4849 RXN.n4 VSS 0.1839f
C4850 RXN.n5 VSS 0.1839f
C4851 RXN.n6 VSS 0.1839f
C4852 RXN.n7 VSS 0.16861f
C4853 TERM_EN6_N.n0 VSS 0.40332f
C4854 TERM_EN6_N.n1 VSS 1.74029f
C4855 TERM_EN6_N.n2 VSS 0.71327f
C4856 TERM_EN5_N.n0 VSS 0.41634f
C4857 TERM_EN5_N.n1 VSS 1.79643f
C4858 TERM_EN5_N.n2 VSS 0.73628f
C4859 TERM_EN4_N.n0 VSS 0.41634f
C4860 TERM_EN4_N.n1 VSS 1.79643f
C4861 TERM_EN4_N.n2 VSS 0.73628f
C4862 TERM_EN3_N.n0 VSS 0.41634f
C4863 TERM_EN3_N.n1 VSS 1.79643f
C4864 TERM_EN3_N.n2 VSS 0.73628f
C4865 TERM_EN2_N.n0 VSS 0.41634f
C4866 TERM_EN2_N.n1 VSS 1.79643f
C4867 TERM_EN2_N.n2 VSS 0.73628f
C4868 TERM_EN1_N.n0 VSS 0.41296f
C4869 TERM_EN1_N.n1 VSS 1.78188f
C4870 TERM_EN1_N.n2 VSS 0.73031f
C4871 TERM_EN0_N.n0 VSS 0.38663f
C4872 TERM_EN0_N.n1 VSS 1.66825f
C4873 TERM_EN0_N.n2 VSS 0.68374f
.ends
