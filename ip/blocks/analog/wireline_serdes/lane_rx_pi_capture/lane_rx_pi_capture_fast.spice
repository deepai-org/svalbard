* SPDX-License-Identifier: Apache-2.0
* Routed phase interpolator driving the fast-converter receive hierarchy.
.include /src/phase_interpolator/phase_interpolator.spice
.include /src/pll/clock_restorer_cascade.spice
.include /src/lane_rx_capture/lane_rx_capture_fast.spice

.subckt lane_rx_pi_capture RXP RXN TERM_EN0_N TERM_EN1_N TERM_EN2_N TERM_EN3_N
+ TERM_EN4_N TERM_EN5_N TERM_EN6_N VTHP VTHN RX_BIAS RX_BW_EN_N REST_BIAS
+ SAMP_BIAS E_SENSE_CLK E_REGEN_CLK E_REGEN_CLKB E_CAPTURE_CLK
+ E_CAPTURE_CLKB E_SENSE_BOOST O_SENSE_CLK O_REGEN_CLK O_REGEN_CLKB
+ O_CAPTURE_CLK O_CAPTURE_CLKB O_SENSE_BOOST VDD VSS
+ PHASE_A_P PHASE_A_N PHASE_B_P PHASE_B_N PI_CTRL_A PI_CTRL_B PI_BUF_BIAS
+ CLK_REST_BIAS PI_RAW_P PI_RAW_N
+ PI_CLK_P PI_CLK_N
+ RX_RAWP RX_RAWN RX_RESTP RX_RESTN SAMP_E_P SAMP_E_N SAMP_O_P SAMP_O_N
+ FE_E_P FE_E_N FE_O_P FE_O_N EVEN_Q EVEN_QB ODD_Q ODD_QB
XPI PHASE_A_P PHASE_A_N PHASE_B_P PHASE_B_N PI_CTRL_A PI_CTRL_B
+ PI_BUF_BIAS VDD VSS PI_RAW_P PI_RAW_N phase_interpolator
XCLKREST PI_RAW_P PI_RAW_N CLK_REST_BIAS VDD VSS PI_CLK_P PI_CLK_N
+ cml_clock_restorer_cascade
XRX RXP RXN TERM_EN0_N TERM_EN1_N TERM_EN2_N TERM_EN3_N TERM_EN4_N
+ TERM_EN5_N TERM_EN6_N VTHP VTHN RX_BIAS RX_BW_EN_N REST_BIAS
+ PI_CLK_P PI_CLK_N SAMP_BIAS E_SENSE_CLK E_REGEN_CLK E_REGEN_CLKB
+ E_CAPTURE_CLK E_CAPTURE_CLKB E_SENSE_BOOST O_SENSE_CLK O_REGEN_CLK
+ O_REGEN_CLKB O_CAPTURE_CLK O_CAPTURE_CLKB O_SENSE_BOOST VDD VSS
+ RX_RAWP RX_RAWN RX_RESTP RX_RESTN SAMP_E_P SAMP_E_N SAMP_O_P SAMP_O_N
+ FE_E_P FE_E_N FE_O_P FE_O_N EVEN_Q EVEN_QB ODD_Q ODD_QB lane_rx_capture
.ends lane_rx_pi_capture
