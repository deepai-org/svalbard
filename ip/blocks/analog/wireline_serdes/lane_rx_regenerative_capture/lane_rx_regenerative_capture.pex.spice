* PEX produced using /foss/tools/sak/sak-pex.sh with m=3 and s=1 (extresist threshold=0 mOhm, minres=1 mOhm, mindelay=0 ps)
* NGSPICE file created from lane_rx_regenerative_capture_pex.ext - technology: gf180mcuD

.subckt lane_rx_regenerative_capture_pex RXP RXN TERM_EN0_N TERM_EN1_N TERM_EN2_N
+ TERM_EN3_N TERM_EN4_N TERM_EN5_N TERM_EN6_N VTHP VTHN RX_BIAS RX_BW_EN_N E_SENSE_CLK
+ E_REGEN_CLK E_REGEN_CLKB E_CAPTURE_CLK E_CAPTURE_CLKB E_SENSE_BOOST O_SENSE_CLK
+ O_REGEN_CLK O_REGEN_CLKB O_CAPTURE_CLK O_CAPTURE_CLKB O_SENSE_BOOST VDD VSS RX_RAWP
+ RX_RAWN FE_E_P FE_E_N FE_O_P FE_O_N EVEN_Q EVEN_QB ODD_Q ODD_QB
X0 XCAP.E_QBI.t8 XCAP.EVEN_D_BUF.t14 XCAP.E_SET_TAIL.t2 VSS.t29 nfet_03v3 ad=2.08p pd=8.52u as=2.08p ps=8.52u w=8u l=0.28u
X1 VSS.t494 RX_BIAS.t4 a_2148_n500.t4 VSS.t491 nfet_03v3 ad=2.6p pd=10.52u as=4.4p ps=20.88u w=10u l=0.28u
X2 a_n10800_n17972.t1 TERM_EN3_N.t2 VSS.t142 VSS.t43 nfet_03v3 ad=0.44p pd=2.88u as=0.44p ps=2.88u w=1u l=0.28u
X3 FE_E_N.t0 XFRONT.XFE_E.H.t17 VSS.t425 VSS.t424 nfet_03v3 ad=3.52p pd=16.88u as=2.08p ps=8.52u w=8u l=0.28u
X4 XCAP.O_RST_TAIL.t11 O_CAPTURE_CLK.t0 VSS.t267 VSS.t266 nfet_03v3 ad=3.52p pd=16.88u as=2.08p ps=8.52u w=8u l=0.28u
X5 XFRONT.XFE_O.NIP.t16 RX_RAWP.t8 XFRONT.XFE_O.NTAIL.t6 VSS.t238 nfet_03v3 ad=2.08p pd=8.52u as=2.08p ps=8.52u w=8u l=0.28u
X6 XCAP.O_QBI.t6 XCAP.ODD_D_BUF.t16 XCAP.O_PRST_TAIL.t0 VDD.t44 pfet_03v3 ad=3.52p pd=16.88u as=2.08p ps=8.52u w=8u l=0.28u
X7 EVEN_Q.t0 XCAP.E_QBBUF.t5 VSS.t5 VSS.t4 nfet_03v3 ad=2.08p pd=8.52u as=2.08p ps=8.52u w=8u l=0.28u
X8 VDD.t352 XFRONT.XFE_O.HB.t28 XFRONT.XFE_O.H.t2 VDD.t351 pfet_03v3 ad=2.08p pd=8.52u as=3.52p ps=16.88u w=8u l=0.28u
X9 XCAP.E_QI.t10 XCAP.E_QBI.t16 VDD.t369 VDD.t2 pfet_03v3 ad=3.52p pd=16.88u as=2.08p ps=8.52u w=8u l=0.28u
X10 XFRONT.XFE_O.XP.t7 XFRONT.XFE_O.XN.t36 XFRONT.XFE_O.NIP.t7 VSS.t184 nfet_03v3 ad=2.08p pd=8.52u as=2.08p ps=8.52u w=8u l=0.28u
X11 VSS.t204 XFRONT.XFE_E.XP.t45 XFRONT.XFE_E.DP.t2 VSS.t203 nfet_03v3 ad=2.08p pd=8.52u as=3.52p ps=16.88u w=8u l=0.28u
X12 a_n7157_n21700.t4 a_n10800_n21572.t3 a_n6400_n21652.t4 VSS.t359 nfet_03v3 ad=4.4p pd=20.88u as=2.6p ps=10.52u w=10u l=0.28u
X13 VSS.t462 E_SENSE_BOOST.t11 XFRONT.XFE_E.NTAIL.t33 VSS.t461 nfet_03v3 ad=2.6p pd=10.52u as=2.6p ps=10.52u w=10u l=0.28u
X14 VDD.t428 XCAP.E_QBUF.t8 EVEN_QB.t4 VDD.t427 pfet_03v3 ad=2.08p pd=8.52u as=2.08p ps=8.52u w=8u l=0.28u
X15 VDD.t92 E_SENSE_CLK.t28 XFRONT.XFE_E.NIN.t3 VDD.t91 pfet_03v3 ad=2.08p pd=8.52u as=2.08p ps=8.52u w=8u l=0.28u
X16 a_2148_n500.t2 a_n6572_3500.t7 RX_RAWP.t2 VSS.t82 nfet_03v3 ad=1.3p pd=5.52u as=2.2p ps=10.88u w=5u l=0.28u
X17 XFRONT.XFE_E.XN.t23 XFRONT.XFE_E.XP.t36 XFRONT.XFE_E.NIN.t7 VSS.t171 nfet_03v3 ad=2.08p pd=8.52u as=2.08p ps=8.52u w=8u l=0.28u
X18 XCAP.ODD_DB_BUF.t9 FE_O_P.t9 VSS.t136 VSS.t135 nfet_03v3 ad=2.08p pd=8.52u as=2.08p ps=8.52u w=8u l=0.28u
X19 XFRONT.XFE_O.NTAIL.t9 RX_RAWP.t5 XFRONT.XFE_O.NIP.t19 VSS.t241 nfet_03v3 ad=2.08p pd=8.52u as=2.08p ps=8.52u w=8u l=0.28u
X20 XFRONT.XFE_E.XP.t9 E_SENSE_CLK.t13 VDD.t120 VDD.t119 pfet_03v3 ad=2.08p pd=8.52u as=2.08p ps=8.52u w=8u l=0.28u
X21 XCAP.E_PSET_TAIL.t5 E_CAPTURE_CLKB.t6 VDD.t254 VDD.t239 pfet_03v3 ad=2.08p pd=8.52u as=2.08p ps=8.52u w=8u l=0.28u
X22 a_n5052_2600.t2 VTHN.t1 a_n3600_5641.t4 VSS.t411 nfet_03v3 ad=0.52p pd=2.52u as=0.88p ps=4.88u w=2u l=0.28u
X23 VSS.t68 E_CAPTURE_CLK.t3 XCAP.E_RST_TAIL.t6 VSS.t17 nfet_03v3 ad=2.08p pd=8.52u as=2.08p ps=8.52u w=8u l=0.28u
X24 XFRONT.XFE_E.NIN.t16 RX_RAWP.t16 XFRONT.XFE_E.NTAIL.t5 VSS.t230 nfet_03v3 ad=2.08p pd=8.52u as=2.08p ps=8.52u w=8u l=0.28u
X25 VDD.t132 FE_E_N.t12 XCAP.EVEN_D_BUF.t6 VDD.t131 pfet_03v3 ad=2.08p pd=8.52u as=2.08p ps=8.52u w=8u l=0.28u
X26 VDD.t203 XFRONT.XFE_O.XP.t53 XFRONT.XFE_O.HB.t8 VDD.t202 pfet_03v3 ad=2.08p pd=8.52u as=3.52p ps=16.88u w=8u l=0.28u
X27 ODD_Q.t6 XCAP.O_QBBUF.t9 VDD.t218 VDD.t217 pfet_03v3 ad=2.08p pd=8.52u as=2.08p ps=8.52u w=8u l=0.28u
X28 XCAP.O_RST_TAIL.t5 O_CAPTURE_CLK.t6 VSS.t260 VSS.t259 nfet_03v3 ad=2.08p pd=8.52u as=2.08p ps=8.52u w=8u l=0.28u
X29 VSS.t482 RX_BIAS.t13 a_n5052_2600.t4 VSS.t481 nfet_03v3 ad=0.52p pd=2.52u as=0.88p ps=4.88u w=2u l=0.28u
X30 XFRONT.XFE_E.NTAIL.t30 E_SENSE_BOOST.t14 VSS.t452 VSS.t451 nfet_03v3 ad=2.6p pd=10.52u as=2.6p ps=10.52u w=10u l=0.28u
X31 VDD.t272 O_SENSE_CLK.t36 XFRONT.XFE_O.XP.t20 VDD.t271 pfet_03v3 ad=2.08p pd=8.52u as=2.08p ps=8.52u w=8u l=0.28u
X32 XFRONT.XFE_O.NIN.t9 XFRONT.XFE_O.XP.t41 XFRONT.XFE_O.XN.t20 VSS.t144 nfet_03v3 ad=2.08p pd=8.52u as=2.08p ps=8.52u w=8u l=0.28u
X33 a_n6400_n18052.t2 a_n10800_n17972.t2 a_n7300_n18100.t2 VSS.t200 nfet_03v3 ad=2.6p pd=10.52u as=4.4p ps=20.88u w=10u l=0.28u
X34 VDD.t169 FE_O_P.t14 XCAP.ODD_DB_BUF.t4 VDD.t168 pfet_03v3 ad=2.08p pd=8.52u as=2.08p ps=8.52u w=8u l=0.28u
X35 VSS.t305 O_SENSE_BOOST.t1 XFRONT.XFE_O.NTAIL.t35 VSS.t304 nfet_03v3 ad=2.6p pd=10.52u as=2.6p ps=10.52u w=10u l=0.28u
X36 XFRONT.XFE_E.NIN.t21 XFRONT.XFE_E.XP.t39 XFRONT.XFE_E.XN.t29 VSS.t421 nfet_03v3 ad=2.08p pd=8.52u as=2.08p ps=8.52u w=8u l=0.28u
X37 XCAP.E_QBI.t5 XCAP.E_QI.t16 VDD.t189 VDD.t188 pfet_03v3 ad=3.52p pd=16.88u as=2.08p ps=8.52u w=8u l=0.28u
X38 VSS.t245 O_CAPTURE_CLK.t13 XCAP.O_SET_TAIL.t6 VSS.t154 nfet_03v3 ad=2.08p pd=8.52u as=2.08p ps=8.52u w=8u l=0.28u
X39 XFRONT.XFE_E.XN.t14 E_SENSE_CLK.t33 VDD.t84 VDD.t83 pfet_03v3 ad=2.08p pd=8.52u as=2.08p ps=8.52u w=8u l=0.28u
X40 VDD.t379 XFRONT.XFE_O.H.t23 XFRONT.XFE_O.HB.t12 VDD.t378 pfet_03v3 ad=2.08p pd=8.52u as=2.08p ps=8.52u w=8u l=0.28u
X41 XFRONT.XFE_O.XN.t16 O_SENSE_CLK.t20 XFRONT.XFE_O.XP.t10 VDD.t293 pfet_03v3 ad=2.08p pd=8.52u as=2.08p ps=8.52u w=8u l=0.28u
X42 VDD.t417 FE_E_P.t18 XCAP.EVEN_DB_BUF.t0 VDD.t416 pfet_03v3 ad=2.08p pd=8.52u as=3.52p ps=16.88u w=8u l=0.28u
X43 XFRONT.XFE_O.XP.t30 XFRONT.XFE_O.XN.t42 XFRONT.XFE_O.NIP.t22 VSS.t502 nfet_03v3 ad=2.08p pd=8.52u as=2.08p ps=8.52u w=8u l=0.28u
X44 VSS.t110 FE_E_N.t10 XCAP.EVEN_D_BUF.t8 VSS.t109 nfet_03v3 ad=2.08p pd=8.52u as=3.52p ps=16.88u w=8u l=0.28u
X45 VDD.t112 E_SENSE_CLK.t18 XFRONT.XFE_E.NIP.t6 VDD.t111 pfet_03v3 ad=2.08p pd=8.52u as=3.52p ps=16.88u w=8u l=0.28u
X46 XCAP.E_RST_TAIL.t9 E_CAPTURE_CLK.t0 VSS.t73 VSS.t72 nfet_03v3 ad=3.52p pd=16.88u as=2.08p ps=8.52u w=8u l=0.28u
X47 VSS.t470 E_SENSE_BOOST.t5 XFRONT.XFE_E.NTAIL.t39 VSS.t469 nfet_03v3 ad=2.6p pd=10.52u as=2.6p ps=10.52u w=10u l=0.28u
X48 XFRONT.XFE_O.H.t7 XFRONT.XFE_O.XN.t52 VDD.t399 VDD.t398 pfet_03v3 ad=3.52p pd=16.88u as=2.08p ps=8.52u w=8u l=0.28u
X49 XFRONT.XFE_O.HB.t14 XFRONT.XFE_O.XP.t50 VDD.t434 VDD.t433 pfet_03v3 ad=3.52p pd=16.88u as=2.08p ps=8.52u w=8u l=0.28u
X50 VDD.t60 FE_O_N.t14 XCAP.ODD_D_BUF.t4 VDD.t59 pfet_03v3 ad=2.08p pd=8.52u as=2.08p ps=8.52u w=8u l=0.28u
X51 a_n6400_n12652.t4 RXN.t6 VSS.t382 ppolyf_u r_width=1u r_length=1u
X52 FE_E_N.t6 XFRONT.XFE_E.H.t22 VDD.t448 VDD.t447 pfet_03v3 ad=3.52p pd=16.88u as=2.08p ps=8.52u w=8u l=0.28u
X53 VDD.t39 XFRONT.XFE_E.XP.t51 XFRONT.XFE_E.XN.t0 VDD.t38 pfet_03v3 ad=2.08p pd=8.52u as=3.52p ps=16.88u w=8u l=0.28u
X54 RXP.t2 a_n7157_n23500.t0 VSS.t115 ppolyf_u r_width=1u r_length=2.43u
X55 FE_O_N.t5 XFRONT.XFE_O.HB.t19 VSS.t333 VSS.t332 nfet_03v3 ad=2.08p pd=8.52u as=2.08p ps=8.52u w=8u l=0.28u
X56 a_n5052_2600.t5 RX_BIAS.t12 VSS.t483 VSS.t481 nfet_03v3 ad=0.52p pd=2.52u as=0.52p ps=2.52u w=2u l=0.28u
X57 XFRONT.XFE_O.XP.t23 O_SENSE_CLK.t33 VDD.t268 VDD.t267 pfet_03v3 ad=2.08p pd=8.52u as=2.08p ps=8.52u w=8u l=0.28u
X58 XCAP.ODD_DB_BUF.t7 FE_O_P.t11 VDD.t163 VDD.t162 pfet_03v3 ad=3.52p pd=16.88u as=2.08p ps=8.52u w=8u l=0.28u
X59 XFRONT.XFE_O.HB.t7 XFRONT.XFE_O.DN.t6 VSS.t375 VSS.t374 nfet_03v3 ad=3.52p pd=16.88u as=2.08p ps=8.52u w=8u l=0.28u
X60 XFRONT.XFE_E.HB.t8 XFRONT.XFE_E.DN.t8 VSS.t175 VSS.t174 nfet_03v3 ad=2.08p pd=8.52u as=2.08p ps=8.52u w=8u l=0.28u
X61 XCAP.O_PSET_TAIL.t7 O_CAPTURE_CLKB.t4 VDD.t343 VDD.t329 pfet_03v3 ad=2.08p pd=8.52u as=2.08p ps=8.52u w=8u l=0.28u
X62 XCAP.O_SET_TAIL.t9 O_CAPTURE_CLK.t10 VSS.t252 VSS.t190 nfet_03v3 ad=2.08p pd=8.52u as=2.08p ps=8.52u w=8u l=0.28u
X63 VDD.t70 E_SENSE_CLK.t36 XFRONT.XFE_E.XN.t11 VDD.t69 pfet_03v3 ad=2.08p pd=8.52u as=2.08p ps=8.52u w=8u l=0.28u
X64 XFRONT.XFE_O.NIP.t4 XFRONT.XFE_O.XN.t39 XFRONT.XFE_O.XP.t4 VSS.t162 nfet_03v3 ad=2.08p pd=8.52u as=2.08p ps=8.52u w=8u l=0.28u
X65 VSS.t507 XCAP.E_QBUF.t4 EVEN_QB.t6 VSS.t506 nfet_03v3 ad=3.52p pd=16.88u as=2.08p ps=8.52u w=8u l=0.28u
X66 XFRONT.XFE_E.NIP.t1 XFRONT.XFE_E.XN.t41 XFRONT.XFE_E.XP.t20 VSS.t14 nfet_03v3 ad=2.08p pd=8.52u as=2.08p ps=8.52u w=8u l=0.28u
X67 XFRONT.XFE_O.NTAIL.t16 O_SENSE_BOOST.t20 VSS.t277 VSS.t276 nfet_03v3 ad=2.6p pd=10.52u as=2.6p ps=10.52u w=10u l=0.28u
X68 XFRONT.XFE_E.NTAIL.t36 E_SENSE_BOOST.t8 VSS.t466 VSS.t465 nfet_03v3 ad=2.6p pd=10.52u as=2.6p ps=10.52u w=10u l=0.28u
X69 XFRONT.XFE_E.NIP.t17 RX_RAWN.t18 XFRONT.XFE_E.NTAIL.t18 VSS.t396 nfet_03v3 ad=2.08p pd=8.52u as=2.08p ps=8.52u w=8u l=0.28u
X70 VDD.t7 XFRONT.XFE_O.XN.t47 XFRONT.XFE_O.DN.t0 VDD.t6 pfet_03v3 ad=2.08p pd=8.52u as=2.08p ps=8.52u w=8u l=0.28u
X71 XCAP.ODD_D_BUF.t7 FE_O_N.t11 VDD.t48 VDD.t47 pfet_03v3 ad=3.52p pd=16.88u as=2.08p ps=8.52u w=8u l=0.28u
X72 XCAP.E_QBUF.t3 XCAP.E_QBI.t14 VSS.t416 VSS.t415 nfet_03v3 ad=1.76p pd=8.88u as=1.04p ps=4.52u w=4u l=0.28u
X73 VSS.t308 O_SENSE_BOOST.t7 XFRONT.XFE_O.NTAIL.t29 VSS.t80 nfet_03v3 ad=2.6p pd=10.52u as=2.6p ps=10.52u w=10u l=0.28u
X74 ODD_Q.t0 XCAP.O_QBBUF.t5 VSS.t1 VSS.t0 nfet_03v3 ad=2.08p pd=8.52u as=2.08p ps=8.52u w=8u l=0.28u
X75 a_n10800_n23372.t1 TERM_EN0_N.t2 VSS.t384 VSS.t43 nfet_03v3 ad=0.44p pd=2.88u as=0.44p ps=2.88u w=1u l=0.28u
X76 VSS.t362 XFRONT.XFE_E.DN.t11 XFRONT.XFE_E.HB.t5 VSS.t361 nfet_03v3 ad=2.08p pd=8.52u as=2.08p ps=8.52u w=8u l=0.28u
X77 XFRONT.XFE_E.DP.t3 XFRONT.XFE_E.XP.t46 VDD.t226 VDD.t225 pfet_03v3 ad=3.52p pd=16.88u as=2.08p ps=8.52u w=8u l=0.28u
X78 XCAP.E_RST_TAIL.t3 E_CAPTURE_CLK.t6 VSS.t66 VSS.t65 nfet_03v3 ad=2.08p pd=8.52u as=2.08p ps=8.52u w=8u l=0.28u
X79 XFRONT.XFE_E.NTAIL.t8 RX_RAWP.t13 XFRONT.XFE_E.NIN.t19 VSS.t233 nfet_03v3 ad=2.08p pd=8.52u as=2.08p ps=8.52u w=8u l=0.28u
X80 VDD.t346 O_CAPTURE_CLKB.t1 XCAP.O_PSET_TAIL.t10 VDD.t337 pfet_03v3 ad=2.08p pd=8.52u as=2.08p ps=8.52u w=8u l=0.28u
X81 XFRONT.XFE_E.XN.t20 E_SENSE_CLK.t26 XFRONT.XFE_E.XP.t0 VDD.t93 pfet_03v3 ad=2.08p pd=8.52u as=3.52p ps=16.88u w=8u l=0.28u
X82 a_n7300_n14500.t1 TERM_EN5_N.t1 a_n6400_n14452.t3 VDD.t363 pfet_03v3 ad=4.4p pd=20.88u as=2.6p ps=10.52u w=10u l=0.28u
X83 XFRONT.XFE_E.NTAIL.t22 E_SENSE_BOOST.t22 VSS.t442 VSS.t441 nfet_03v3 ad=2.6p pd=10.52u as=2.6p ps=10.52u w=10u l=0.28u
X84 XFRONT.XFE_E.HB.t13 XFRONT.XFE_E.H.t27 VDD.t454 VDD.t453 pfet_03v3 ad=2.08p pd=8.52u as=2.08p ps=8.52u w=8u l=0.28u
X85 VDD.t468 XFRONT.XFE_O.HB.t26 XFRONT.XFE_O.H.t4 VDD.t467 pfet_03v3 ad=2.08p pd=8.52u as=2.08p ps=8.52u w=8u l=0.28u
X86 XCAP.EVEN_DB_BUF.t9 FE_E_P.t9 VSS.t389 VSS.t388 nfet_03v3 ad=2.08p pd=8.52u as=2.08p ps=8.52u w=8u l=0.28u
X87 XCAP.ODD_DB_BUF.t1 FE_O_P.t17 VDD.t161 VDD.t160 pfet_03v3 ad=2.08p pd=8.52u as=2.08p ps=8.52u w=8u l=0.28u
X88 XFRONT.XFE_O.HB.t1 XFRONT.XFE_O.DN.t12 VSS.t370 VSS.t369 nfet_03v3 ad=2.08p pd=8.52u as=2.08p ps=8.52u w=8u l=0.28u
X89 XFRONT.XFE_O.NTAIL.t32 O_SENSE_BOOST.t4 VSS.t313 VSS.t312 nfet_03v3 ad=2.6p pd=10.52u as=2.6p ps=10.52u w=10u l=0.28u
X90 EVEN_Q.t6 XCAP.E_QBBUF.t7 VDD.t458 VDD.t457 pfet_03v3 ad=3.52p pd=16.88u as=2.08p ps=8.52u w=8u l=0.28u
X91 XFRONT.XFE_E.H.t11 XFRONT.XFE_E.DP.t6 VSS.t420 VSS.t419 nfet_03v3 ad=3.52p pd=16.88u as=2.08p ps=8.52u w=8u l=0.28u
X92 XFRONT.XFE_O.XP.t14 O_SENSE_CLK.t23 XFRONT.XFE_O.XN.t13 VDD.t290 pfet_03v3 ad=2.08p pd=8.52u as=2.08p ps=8.52u w=8u l=0.28u
X93 XCAP.E_PSET_TAIL.t3 XCAP.EVEN_DB_BUF.t19 XCAP.E_QI.t4 VDD.t16 pfet_03v3 ad=2.08p pd=8.52u as=3.52p ps=16.88u w=8u l=0.28u
X94 XCAP.EVEN_D_BUF.t11 FE_E_N.t7 VSS.t114 VSS.t113 nfet_03v3 ad=3.52p pd=16.88u as=2.08p ps=8.52u w=8u l=0.28u
X95 XFRONT.XFE_E.NIP.t9 E_SENSE_CLK.t15 VDD.t118 VDD.t117 pfet_03v3 ad=3.52p pd=16.88u as=2.08p ps=8.52u w=8u l=0.28u
X96 VDD.t62 XFRONT.XFE_E.XP.t49 XFRONT.XFE_E.DP.t0 VDD.t61 pfet_03v3 ad=2.08p pd=8.52u as=3.52p ps=16.88u w=8u l=0.28u
X97 XFRONT.XFE_O.XN.t7 O_SENSE_CLK.t7 VDD.t316 VDD.t315 pfet_03v3 ad=2.08p pd=8.52u as=2.08p ps=8.52u w=8u l=0.28u
X98 ODD_QB.t4 XCAP.O_QBUF.t7 VDD.t35 VDD.t34 pfet_03v3 ad=3.52p pd=16.88u as=2.08p ps=8.52u w=8u l=0.28u
X99 XFRONT.XFE_E.NIP.t23 RX_RAWN.t12 XFRONT.XFE_E.NTAIL.t20 VSS.t402 nfet_03v3 ad=3.52p pd=16.88u as=2.08p ps=8.52u w=8u l=0.28u
X100 a_n5052_n1000.t5 RX_BIAS.t8 VSS.t488 VSS.t487 nfet_03v3 ad=2.6p pd=10.52u as=2.6p ps=10.52u w=10u l=0.28u
X101 a_n10800_n12572.t0 TERM_EN6_N.t3 VDD.t28 VDD.t27 pfet_03v3 ad=0.88p pd=4.88u as=0.88p ps=4.88u w=2u l=0.28u
X102 XFRONT.XFE_E.NTAIL.t0 E_SENSE_CLK.t4 VSS.t100 VSS.t99 nfet_03v3 ad=2.6p pd=10.52u as=4.4p ps=20.88u w=10u l=0.28u
X103 VDD.t464 XFRONT.XFE_O.XN.t55 XFRONT.XFE_O.H.t8 VDD.t463 pfet_03v3 ad=2.08p pd=8.52u as=3.52p ps=16.88u w=8u l=0.28u
X104 VDD.t88 E_SENSE_CLK.t30 XFRONT.XFE_E.NIN.t1 VDD.t87 pfet_03v3 ad=2.08p pd=8.52u as=3.52p ps=16.88u w=8u l=0.28u
X105 XCAP.ODD_D_BUF.t1 FE_O_N.t17 VDD.t50 VDD.t49 pfet_03v3 ad=2.08p pd=8.52u as=2.08p ps=8.52u w=8u l=0.28u
X106 XCAP.E_PSET_TAIL.t7 E_CAPTURE_CLKB.t4 VDD.t256 VDD.t184 pfet_03v3 ad=2.08p pd=8.52u as=2.08p ps=8.52u w=8u l=0.28u
X107 FE_O_N.t1 XFRONT.XFE_O.HB.t23 VDD.t356 VDD.t355 pfet_03v3 ad=2.08p pd=8.52u as=2.08p ps=8.52u w=8u l=0.28u
X108 XFRONT.XFE_E.H.t16 XFRONT.XFE_E.HB.t22 VDD.t389 VDD.t388 pfet_03v3 ad=3.52p pd=16.88u as=2.08p ps=8.52u w=8u l=0.28u
X109 FE_O_P.t5 XFRONT.XFE_O.H.t18 VSS.t345 VSS.t344 nfet_03v3 ad=3.52p pd=16.88u as=2.08p ps=8.52u w=8u l=0.28u
X110 a_n7300_n18100.t0 TERM_EN3_N.t1 a_n6400_n18052.t0 VDD.t172 pfet_03v3 ad=4.4p pd=20.88u as=2.6p ps=10.52u w=10u l=0.28u
X111 RX_RAWP.t1 RX_BW_EN_N.t1 a_484_3500.t0 VDD.t349 pfet_03v3 ad=2.2p pd=10.88u as=2.2p ps=10.88u w=5u l=0.28u
X112 a_n6400_n16252.t0 RXN.t0 VSS.t96 ppolyf_u r_width=1u r_length=1u
X113 VSS.t356 XFRONT.XFE_O.DN.t9 XFRONT.XFE_O.HB.t4 VSS.t355 nfet_03v3 ad=2.08p pd=8.52u as=2.08p ps=8.52u w=8u l=0.28u
X114 XFRONT.XFE_O.NTAIL.t40 RX_RAWN.t11 XFRONT.XFE_O.NIN.t16 VSS.t403 nfet_03v3 ad=2.08p pd=8.52u as=3.52p ps=16.88u w=8u l=0.28u
X115 VDD.t234 XCAP.E_QBBUF.t10 EVEN_Q.t3 VDD.t233 pfet_03v3 ad=2.08p pd=8.52u as=3.52p ps=16.88u w=8u l=0.28u
X116 XCAP.O_RST_TAIL.t7 O_CAPTURE_CLK.t4 VSS.t261 VSS.t37 nfet_03v3 ad=2.08p pd=8.52u as=2.08p ps=8.52u w=8u l=0.28u
X117 VSS.t220 O_SENSE_CLK.t4 XFRONT.XFE_O.NTAIL.t0 VSS.t219 nfet_03v3 ad=2.6p pd=10.52u as=4.4p ps=20.88u w=10u l=0.28u
X118 XFRONT.XFE_E.DN.t2 XFRONT.XFE_E.XN.t48 VDD.t146 VDD.t145 pfet_03v3 ad=2.08p pd=8.52u as=2.08p ps=8.52u w=8u l=0.28u
X119 XCAP.E_QBBUF.t1 XCAP.E_QI.t18 VDD.t186 VDD.t137 pfet_03v3 ad=3.52p pd=16.88u as=2.08p ps=8.52u w=8u l=0.28u
X120 a_n6400_n23452.t1 a_n10800_n23372.t2 a_n7157_n23500.t1 VSS.t354 nfet_03v3 ad=2.6p pd=10.52u as=4.4p ps=20.88u w=10u l=0.28u
X121 VDD.t450 XCAP.O_QI.t19 XCAP.O_QBBUF.t0 VDD.t57 pfet_03v3 ad=2.08p pd=8.52u as=3.52p ps=16.88u w=8u l=0.28u
X122 VSS.t271 O_SENSE_BOOST.t23 XFRONT.XFE_O.NTAIL.t13 VSS.t270 nfet_03v3 ad=2.6p pd=10.52u as=4.4p ps=20.88u w=10u l=0.28u
X123 XFRONT.XFE_E.NTAIL.t28 E_SENSE_BOOST.t16 VSS.t450 VSS.t25 nfet_03v3 ad=2.6p pd=10.52u as=2.6p ps=10.52u w=10u l=0.28u
X124 XFRONT.XFE_E.XP.t17 E_SENSE_CLK.t5 VDD.t106 VDD.t105 pfet_03v3 ad=3.52p pd=16.88u as=2.08p ps=8.52u w=8u l=0.28u
X125 XFRONT.XFE_E.NTAIL.t15 RX_RAWN.t15 XFRONT.XFE_E.NIP.t20 VSS.t399 nfet_03v3 ad=2.08p pd=8.52u as=2.08p ps=8.52u w=8u l=0.28u
X126 XFRONT.XFE_E.H.t0 XFRONT.XFE_E.HB.t17 VSS.t128 VSS.t127 nfet_03v3 ad=3.52p pd=16.88u as=3.52p ps=16.88u w=8u l=0.28u
X127 RX_RAWN.t3 a_n3600_5641.t6 a_2148_n500.t1 VSS.t82 nfet_03v3 ad=2.2p pd=10.88u as=1.3p ps=5.52u w=5u l=0.28u
X128 VDD.t270 O_SENSE_CLK.t32 XFRONT.XFE_O.XP.t24 VDD.t269 pfet_03v3 ad=2.08p pd=8.52u as=2.08p ps=8.52u w=8u l=0.28u
X129 a_n1900_5958.t0 RX_BW_EN_N.t2 a_n3600_5641.t3 VDD.t348 pfet_03v3 ad=2.2p pd=10.88u as=2.2p ps=10.88u w=5u l=0.28u
X130 a_n6400_n12652.t1 TERM_EN6_N.t0 a_n7300_n12700.t1 VDD.t30 pfet_03v3 ad=2.6p pd=10.52u as=4.4p ps=20.88u w=10u l=0.28u
X131 VDD.t258 E_CAPTURE_CLKB.t1 XCAP.E_PSET_TAIL.t10 VDD.t243 pfet_03v3 ad=2.08p pd=8.52u as=2.08p ps=8.52u w=8u l=0.28u
X132 XCAP.O_QI.t3 XCAP.O_QBI.t12 VSS.t151 VSS.t150 nfet_03v3 ad=3.52p pd=16.88u as=2.08p ps=8.52u w=8u l=0.28u
X133 VDD.t197 XFRONT.XFE_E.HB.t25 XFRONT.XFE_E.H.t1 VDD.t196 pfet_03v3 ad=2.08p pd=8.52u as=3.52p ps=16.88u w=8u l=0.28u
X134 VDD.t452 XCAP.O_QI.t17 XCAP.O_QBI.t1 VDD.t329 pfet_03v3 ad=2.08p pd=8.52u as=3.52p ps=16.88u w=8u l=0.28u
X135 XCAP.EVEN_D_BUF.t1 FE_E_N.t17 VDD.t134 VDD.t133 pfet_03v3 ad=2.08p pd=8.52u as=2.08p ps=8.52u w=8u l=0.28u
X136 VSS.t265 O_CAPTURE_CLK.t1 XCAP.O_RST_TAIL.t10 VSS.t264 nfet_03v3 ad=2.08p pd=8.52u as=2.08p ps=8.52u w=8u l=0.28u
X137 XFRONT.XFE_O.NTAIL.t3 O_SENSE_CLK.t1 VSS.t224 VSS.t223 nfet_03v3 ad=2.6p pd=10.52u as=2.6p ps=10.52u w=10u l=0.28u
X138 XCAP.O_PRST_TAIL.t2 XCAP.ODD_D_BUF.t17 XCAP.O_QBI.t10 VDD.t12 pfet_03v3 ad=2.08p pd=8.52u as=2.08p ps=8.52u w=8u l=0.28u
X139 RXP.t4 a_n7300_n12700.t4 VSS.t115 ppolyf_u r_width=1u r_length=1u
X140 VSS.t448 E_SENSE_BOOST.t19 XFRONT.XFE_E.NTAIL.t25 VSS.t447 nfet_03v3 ad=2.6p pd=10.52u as=2.6p ps=10.52u w=10u l=0.28u
X141 VSS.t413 XCAP.E_QBBUF.t4 EVEN_Q.t5 VSS.t412 nfet_03v3 ad=3.52p pd=16.88u as=2.08p ps=8.52u w=8u l=0.28u
X142 a_n6400_n19852.t2 RXN.t4 VSS.t321 ppolyf_u r_width=1u r_length=1u
X143 XFRONT.XFE_O.XN.t25 XFRONT.XFE_O.XP.t36 XFRONT.XFE_O.NIN.t4 VSS.t46 nfet_03v3 ad=2.08p pd=8.52u as=2.08p ps=8.52u w=8u l=0.28u
X144 VSS.t52 E_CAPTURE_CLK.t15 XCAP.E_SET_TAIL.t4 VSS.t51 nfet_03v3 ad=2.08p pd=8.52u as=3.52p ps=16.88u w=8u l=0.28u
X145 VDD.t193 XFRONT.XFE_O.H.t28 FE_O_P.t1 VDD.t192 pfet_03v3 ad=2.08p pd=8.52u as=3.52p ps=16.88u w=8u l=0.28u
X146 VDD.t78 E_SENSE_CLK.t38 XFRONT.XFE_E.XN.t9 VDD.t77 pfet_03v3 ad=2.08p pd=8.52u as=2.08p ps=8.52u w=8u l=0.28u
X147 XCAP.O_SET_TAIL.t11 O_CAPTURE_CLK.t8 VSS.t256 VSS.t255 nfet_03v3 ad=3.52p pd=16.88u as=2.08p ps=8.52u w=8u l=0.28u
X148 a_n6572_3500.t3 RX_BW_EN_N.t3 a_n6716_3500.t1 VDD.t347 pfet_03v3 ad=2.2p pd=10.88u as=2.2p ps=10.88u w=5u l=0.28u
X149 XFRONT.XFE_E.DP.t1 XFRONT.XFE_E.XP.t44 VSS.t124 VSS.t123 nfet_03v3 ad=3.52p pd=16.88u as=2.08p ps=8.52u w=8u l=0.28u
X150 XCAP.O_PSET_TAIL.t2 XCAP.ODD_DB_BUF.t19 XCAP.O_QI.t2 VDD.t23 pfet_03v3 ad=2.08p pd=8.52u as=3.52p ps=16.88u w=8u l=0.28u
X151 XCAP.E_RST_TAIL.t0 XCAP.EVEN_DB_BUF.t15 XCAP.E_QI.t0 VSS.t33 nfet_03v3 ad=2.08p pd=8.52u as=3.52p ps=16.88u w=8u l=0.28u
X152 XFRONT.XFE_E.NTAIL.t34 E_SENSE_BOOST.t10 VSS.t464 VSS.t463 nfet_03v3 ad=2.6p pd=10.52u as=2.6p ps=10.52u w=10u l=0.28u
X153 VSS.t209 XFRONT.XFE_E.DP.t7 XFRONT.XFE_E.H.t10 VSS.t208 nfet_03v3 ad=2.08p pd=8.52u as=2.08p ps=8.52u w=8u l=0.28u
X154 VDD.t314 O_SENSE_CLK.t10 XFRONT.XFE_O.XN.t4 VDD.t313 pfet_03v3 ad=2.08p pd=8.52u as=2.08p ps=8.52u w=8u l=0.28u
X155 VDD.t26 XCAP.O_QBUF.t10 ODD_QB.t1 VDD.t25 pfet_03v3 ad=2.08p pd=8.52u as=3.52p ps=16.88u w=8u l=0.28u
X156 VSS.t496 RX_BIAS.t2 a_2148_n500.t6 VSS.t491 nfet_03v3 ad=2.6p pd=10.52u as=2.6p ps=10.52u w=10u l=0.28u
X157 VDD.t460 XFRONT.XFE_E.HB.t27 FE_E_P.t5 VDD.t459 pfet_03v3 ad=2.08p pd=8.52u as=2.08p ps=8.52u w=8u l=0.28u
X158 EVEN_QB.t2 XCAP.E_QBUF.t9 VDD.t195 VDD.t194 pfet_03v3 ad=2.08p pd=8.52u as=2.08p ps=8.52u w=8u l=0.28u
X159 XFRONT.XFE_E.NIN.t4 E_SENSE_CLK.t27 VDD.t86 VDD.t85 pfet_03v3 ad=3.52p pd=16.88u as=2.08p ps=8.52u w=8u l=0.28u
X160 XFRONT.XFE_E.NIP.t5 XFRONT.XFE_E.XN.t33 XFRONT.XFE_E.XP.t28 VSS.t32 nfet_03v3 ad=2.08p pd=8.52u as=2.08p ps=8.52u w=8u l=0.28u
X161 a_n10800_n16172.t0 TERM_EN4_N.t3 VDD.t366 VDD.t365 pfet_03v3 ad=0.88p pd=4.88u as=0.88p ps=4.88u w=2u l=0.28u
X162 VSS.t341 XFRONT.XFE_O.H.t21 FE_O_P.t4 VSS.t340 nfet_03v3 ad=2.08p pd=8.52u as=3.52p ps=16.88u w=8u l=0.28u
X163 VDD.t328 O_CAPTURE_CLKB.t15 XCAP.O_PRST_TAIL.t4 VDD.t327 pfet_03v3 ad=2.08p pd=8.52u as=3.52p ps=16.88u w=8u l=0.28u
X164 XCAP.E_RST_TAIL.t5 E_CAPTURE_CLK.t4 VSS.t48 VSS.t29 nfet_03v3 ad=2.08p pd=8.52u as=2.08p ps=8.52u w=8u l=0.28u
X165 XFRONT.XFE_O.XP.t2 XFRONT.XFE_O.XN.t34 XFRONT.XFE_O.NIP.t2 VSS.t22 nfet_03v3 ad=2.08p pd=8.52u as=2.08p ps=8.52u w=8u l=0.28u
X166 XCAP.EVEN_D_BUF.t7 FE_E_N.t11 VDD.t144 VDD.t143 pfet_03v3 ad=3.52p pd=16.88u as=2.08p ps=8.52u w=8u l=0.28u
X167 VSS.t287 O_SENSE_BOOST.t15 XFRONT.XFE_O.NTAIL.t21 VSS.t286 nfet_03v3 ad=2.6p pd=10.52u as=2.6p ps=10.52u w=10u l=0.28u
X168 XCAP.O_QI.t6 XCAP.ODD_DB_BUF.t16 XCAP.O_PSET_TAIL.t3 VDD.t44 pfet_03v3 ad=3.52p pd=16.88u as=2.08p ps=8.52u w=8u l=0.28u
X169 VSS.t454 E_SENSE_BOOST.t13 XFRONT.XFE_E.NTAIL.t31 VSS.t453 nfet_03v3 ad=2.6p pd=10.52u as=2.6p ps=10.52u w=10u l=0.28u
X170 XFRONT.XFE_E.H.t7 XFRONT.XFE_E.DP.t10 VSS.t202 VSS.t201 nfet_03v3 ad=2.08p pd=8.52u as=2.08p ps=8.52u w=8u l=0.28u
X171 XFRONT.XFE_O.XN.t19 XFRONT.XFE_O.XP.t42 XFRONT.XFE_O.NIN.t10 VSS.t145 nfet_03v3 ad=2.08p pd=8.52u as=2.08p ps=8.52u w=8u l=0.28u
X172 VSS.t177 XFRONT.XFE_E.HB.t19 FE_E_P.t2 VSS.t176 nfet_03v3 ad=2.08p pd=8.52u as=2.08p ps=8.52u w=8u l=0.28u
X173 VDD.t72 E_SENSE_CLK.t32 XFRONT.XFE_E.XN.t15 VDD.t71 pfet_03v3 ad=2.08p pd=8.52u as=2.08p ps=8.52u w=8u l=0.28u
X174 XFRONT.XFE_O.NTAIL.t34 O_SENSE_BOOST.t2 VSS.t303 VSS.t302 nfet_03v3 ad=2.6p pd=10.52u as=2.6p ps=10.52u w=10u l=0.28u
X175 VDD.t185 XCAP.E_QI.t17 XCAP.E_QBI.t4 VDD.t184 pfet_03v3 ad=2.08p pd=8.52u as=3.52p ps=16.88u w=8u l=0.28u
X176 XCAP.O_SET_TAIL.t5 O_CAPTURE_CLK.t14 VSS.t249 VSS.t248 nfet_03v3 ad=2.08p pd=8.52u as=2.08p ps=8.52u w=8u l=0.28u
X177 XFRONT.XFE_O.HB.t9 XFRONT.XFE_O.H.t24 VDD.t371 VDD.t370 pfet_03v3 ad=2.08p pd=8.52u as=2.08p ps=8.52u w=8u l=0.28u
X178 XFRONT.XFE_E.NIN.t14 RX_RAWP.t18 XFRONT.XFE_E.NTAIL.t11 VSS.t228 nfet_03v3 ad=2.08p pd=8.52u as=2.08p ps=8.52u w=8u l=0.28u
X179 VSS.t71 E_CAPTURE_CLK.t1 XCAP.E_RST_TAIL.t8 VSS.t70 nfet_03v3 ad=2.08p pd=8.52u as=2.08p ps=8.52u w=8u l=0.28u
X180 VSS.t349 XFRONT.XFE_O.DP.t13 XFRONT.XFE_O.H.t9 VSS.t348 nfet_03v3 ad=2.08p pd=8.52u as=3.52p ps=16.88u w=8u l=0.28u
X181 VDD.t138 FE_E_N.t14 XCAP.EVEN_D_BUF.t4 VDD.t137 pfet_03v3 ad=2.08p pd=8.52u as=2.08p ps=8.52u w=8u l=0.28u
X182 VDD.t436 XFRONT.XFE_O.XP.t51 XFRONT.XFE_O.HB.t15 VDD.t435 pfet_03v3 ad=2.08p pd=8.52u as=2.08p ps=8.52u w=8u l=0.28u
X183 a_n6400_n16252.t3 TERM_EN4_N.t0 a_n7300_n16300.t4 VDD.t368 pfet_03v3 ad=2.6p pd=10.52u as=4.4p ps=20.88u w=10u l=0.28u
X184 VDD.t220 XFRONT.XFE_O.XN.t53 XFRONT.XFE_O.H.t0 VDD.t219 pfet_03v3 ad=2.08p pd=8.52u as=2.08p ps=8.52u w=8u l=0.28u
X185 XCAP.ODD_D_BUF.t3 FE_O_N.t15 VDD.t58 VDD.t57 pfet_03v3 ad=2.08p pd=8.52u as=2.08p ps=8.52u w=8u l=0.28u
X186 a_n10800_n19772.t0 TERM_EN2_N.t3 VDD.t151 VDD.t150 pfet_03v3 ad=0.88p pd=4.88u as=0.88p ps=4.88u w=2u l=0.28u
X187 XFRONT.XFE_E.XN.t1 XFRONT.XFE_E.XP.t50 VDD.t64 VDD.t63 pfet_03v3 ad=3.52p pd=16.88u as=2.08p ps=8.52u w=8u l=0.28u
X188 XFRONT.XFE_E.XP.t7 E_SENSE_CLK.t19 XFRONT.XFE_E.XN.t5 VDD.t100 pfet_03v3 ad=3.52p pd=16.88u as=2.08p ps=8.52u w=8u l=0.28u
X189 XFRONT.XFE_O.NIN.t1 XFRONT.XFE_O.XP.t39 XFRONT.XFE_O.XN.t22 VSS.t7 nfet_03v3 ad=2.08p pd=8.52u as=2.08p ps=8.52u w=8u l=0.28u
X190 VDD.t167 FE_O_P.t12 XCAP.ODD_DB_BUF.t6 VDD.t166 pfet_03v3 ad=2.08p pd=8.52u as=2.08p ps=8.52u w=8u l=0.28u
X191 XCAP.E_SET_TAIL.t11 E_CAPTURE_CLK.t8 VSS.t64 VSS.t63 nfet_03v3 ad=3.52p pd=16.88u as=2.08p ps=8.52u w=8u l=0.28u
X192 VSS.t351 XFRONT.XFE_O.DN.t7 XFRONT.XFE_O.HB.t6 VSS.t350 nfet_03v3 ad=2.08p pd=8.52u as=2.08p ps=8.52u w=8u l=0.28u
X193 XFRONT.XFE_E.XN.t12 E_SENSE_CLK.t35 VDD.t82 VDD.t81 pfet_03v3 ad=2.08p pd=8.52u as=2.08p ps=8.52u w=8u l=0.28u
X194 XFRONT.XFE_O.NTAIL.t38 RX_RAWN.t9 XFRONT.XFE_O.NIN.t18 VSS.t405 nfet_03v3 ad=2.08p pd=8.52u as=2.08p ps=8.52u w=8u l=0.28u
X195 XFRONT.XFE_E.NIN.t23 XFRONT.XFE_E.XP.t41 XFRONT.XFE_E.XN.t31 VSS.t423 nfet_03v3 ad=2.08p pd=8.52u as=2.08p ps=8.52u w=8u l=0.28u
X196 VSS.t251 O_CAPTURE_CLK.t11 XCAP.O_SET_TAIL.t8 VSS.t150 nfet_03v3 ad=2.08p pd=8.52u as=2.08p ps=8.52u w=8u l=0.28u
X197 RXP.t1 a_n7300_n16300.t2 VSS.t115 ppolyf_u r_width=1u r_length=1u
X198 XFRONT.XFE_O.XP.t5 XFRONT.XFE_O.XN.t40 XFRONT.XFE_O.NIP.t5 VSS.t163 nfet_03v3 ad=2.08p pd=8.52u as=2.08p ps=8.52u w=8u l=0.28u
X199 VSS.t3 XCAP.O_QBUF.t6 ODD_QB.t0 VSS.t2 nfet_03v3 ad=2.08p pd=8.52u as=3.52p ps=16.88u w=8u l=0.28u
X200 XFRONT.XFE_O.DP.t2 XFRONT.XFE_O.XP.t46 VDD.t1 VDD.t0 pfet_03v3 ad=3.52p pd=16.88u as=2.08p ps=8.52u w=8u l=0.28u
X201 EVEN_QB.t5 XCAP.E_QBUF.t5 VSS.t505 VSS.t504 nfet_03v3 ad=2.08p pd=8.52u as=2.08p ps=8.52u w=8u l=0.28u
X202 VSS.t275 O_SENSE_BOOST.t21 XFRONT.XFE_O.NTAIL.t15 VSS.t274 nfet_03v3 ad=2.6p pd=10.52u as=2.6p ps=10.52u w=10u l=0.28u
X203 XFRONT.XFE_E.NTAIL.t13 RX_RAWN.t17 XFRONT.XFE_E.NIP.t18 VSS.t397 nfet_03v3 ad=2.08p pd=8.52u as=2.08p ps=8.52u w=8u l=0.28u
X204 XCAP.O_RST_TAIL.t0 XCAP.ODD_DB_BUF.t15 XCAP.O_QI.t5 VSS.t154 nfet_03v3 ad=2.08p pd=8.52u as=3.52p ps=16.88u w=8u l=0.28u
X205 XFRONT.XFE_O.DN.t1 XFRONT.XFE_O.XN.t48 VDD.t9 VDD.t8 pfet_03v3 ad=2.08p pd=8.52u as=2.08p ps=8.52u w=8u l=0.28u
X206 VDD.t52 FE_O_N.t12 XCAP.ODD_D_BUF.t6 VDD.t51 pfet_03v3 ad=2.08p pd=8.52u as=2.08p ps=8.52u w=8u l=0.28u
X207 VSS.t326 XCAP.E_QBI.t15 XCAP.E_QBUF.t2 VSS.t325 nfet_03v3 ad=1.04p pd=4.52u as=1.76p ps=8.88u w=4u l=0.28u
X208 FE_E_N.t3 XFRONT.XFE_E.H.t24 VDD.t442 VDD.t441 pfet_03v3 ad=2.08p pd=8.52u as=3.52p ps=16.88u w=8u l=0.28u
X209 VDD.t249 E_CAPTURE_CLKB.t15 XCAP.E_PRST_TAIL.t4 VDD.t245 pfet_03v3 ad=2.08p pd=8.52u as=3.52p ps=16.88u w=8u l=0.28u
X210 a_n5052_2600.t7 RX_BIAS.t10 VSS.t486 VSS.t484 nfet_03v3 ad=0.88p pd=4.88u as=0.52p ps=2.52u w=2u l=0.28u
X211 a_n6572_3500.t5 RXP.t8 a_n5052_n1000.t2 VSS.t383 nfet_03v3 ad=4.4p pd=20.88u as=2.6p ps=10.52u w=10u l=0.28u
X212 a_n6400_n19852.t0 TERM_EN2_N.t0 a_n7300_n19900.t1 VDD.t153 pfet_03v3 ad=2.6p pd=10.52u as=4.4p ps=20.88u w=10u l=0.28u
X213 a_n3600_5641.t5 VTHN.t0 a_n5052_2600.t3 VSS.t411 nfet_03v3 ad=0.88p pd=4.88u as=0.52p ps=2.52u w=2u l=0.28u
X214 XFRONT.XFE_E.NIN.t20 RX_RAWP.t12 XFRONT.XFE_E.NTAIL.t9 VSS.t234 nfet_03v3 ad=3.52p pd=16.88u as=2.08p ps=8.52u w=8u l=0.28u
X215 XFRONT.XFE_O.NIN.t21 RX_RAWN.t6 XFRONT.XFE_O.NTAIL.t44 VSS.t408 nfet_03v3 ad=2.08p pd=8.52u as=2.08p ps=8.52u w=8u l=0.28u
X216 XCAP.E_QBI.t10 XCAP.EVEN_D_BUF.t16 XCAP.E_PRST_TAIL.t2 VDD.t24 pfet_03v3 ad=3.52p pd=16.88u as=2.08p ps=8.52u w=8u l=0.28u
X217 XFRONT.XFE_O.NIP.t8 XFRONT.XFE_O.XN.t37 XFRONT.XFE_O.XP.t8 VSS.t185 nfet_03v3 ad=2.08p pd=8.52u as=2.08p ps=8.52u w=8u l=0.28u
X218 XFRONT.XFE_O.NIP.t12 O_SENSE_CLK.t27 VDD.t286 VDD.t285 pfet_03v3 ad=3.52p pd=16.88u as=2.08p ps=8.52u w=8u l=0.28u
X219 a_n7157_n23500.t3 TERM_EN0_N.t1 a_n6400_n23452.t3 VDD.t408 pfet_03v3 ad=4.4p pd=20.88u as=2.6p ps=10.52u w=10u l=0.28u
X220 XFRONT.XFE_O.NTAIL.t18 O_SENSE_BOOST.t18 VSS.t279 VSS.t278 nfet_03v3 ad=2.6p pd=10.52u as=2.6p ps=10.52u w=10u l=0.28u
X221 XCAP.E_QBUF.t1 XCAP.E_QBI.t18 VDD.t230 VDD.t229 pfet_03v3 ad=3.52p pd=16.88u as=2.08p ps=8.52u w=8u l=0.28u
X222 VDD.t446 XFRONT.XFE_E.H.t26 XFRONT.XFE_E.HB.t14 VDD.t445 pfet_03v3 ad=2.08p pd=8.52u as=2.08p ps=8.52u w=8u l=0.28u
X223 VDD.t104 E_SENSE_CLK.t10 XFRONT.XFE_E.XP.t12 VDD.t103 pfet_03v3 ad=2.08p pd=8.52u as=2.08p ps=8.52u w=8u l=0.28u
X224 VSS.t391 FE_E_P.t8 XCAP.EVEN_DB_BUF.t10 VSS.t390 nfet_03v3 ad=2.08p pd=8.52u as=2.08p ps=8.52u w=8u l=0.28u
X225 RXP.t7 a_n7300_n19900.t4 VSS.t115 ppolyf_u r_width=1u r_length=1u
X226 VSS.t343 XFRONT.XFE_O.H.t17 XFRONT.XFE_O.HB.t13 VSS.t342 nfet_03v3 ad=3.52p pd=16.88u as=3.52p ps=16.88u w=8u l=0.28u
X227 XCAP.O_QI.t11 XCAP.ODD_DB_BUF.t12 XCAP.O_RST_TAIL.t3 VSS.t190 nfet_03v3 ad=3.52p pd=16.88u as=2.08p ps=8.52u w=8u l=0.28u
X228 VDD.t208 RX_RAWN.t1 VSS.t182 ppolyf_u r_width=2u r_length=3.43u
X229 XFRONT.XFE_E.HB.t1 XFRONT.XFE_E.XP.t54 VDD.t20 VDD.t19 pfet_03v3 ad=2.08p pd=8.52u as=2.08p ps=8.52u w=8u l=0.28u
X230 a_n7300_n14500.t0 a_n10800_n14372.t3 a_n6400_n14452.t1 VSS.t214 nfet_03v3 ad=4.4p pd=20.88u as=2.6p ps=10.52u w=10u l=0.28u
X231 a_n10800_n12572.t1 TERM_EN6_N.t2 VSS.t44 VSS.t43 nfet_03v3 ad=0.44p pd=2.88u as=0.44p ps=2.88u w=1u l=0.28u
X232 XFRONT.XFE_E.NTAIL.t4 E_SENSE_CLK.t0 VSS.t106 VSS.t105 nfet_03v3 ad=4.4p pd=20.88u as=2.6p ps=10.52u w=10u l=0.28u
X233 VSS.t170 XFRONT.XFE_E.DN.t13 XFRONT.XFE_E.HB.t3 VSS.t169 nfet_03v3 ad=2.08p pd=8.52u as=3.52p ps=16.88u w=8u l=0.28u
X234 VDD.t33 XCAP.O_QBUF.t8 ODD_QB.t3 VDD.t32 pfet_03v3 ad=2.08p pd=8.52u as=2.08p ps=8.52u w=8u l=0.28u
X235 XFRONT.XFE_E.NTAIL.t6 RX_RAWP.t15 XFRONT.XFE_E.NIN.t17 VSS.t231 nfet_03v3 ad=2.08p pd=8.52u as=2.08p ps=8.52u w=8u l=0.28u
X236 XFRONT.XFE_O.XP.t17 O_SENSE_CLK.t39 VDD.t260 VDD.t259 pfet_03v3 ad=2.08p pd=8.52u as=2.08p ps=8.52u w=8u l=0.28u
X237 VSS.t498 RX_BIAS.t0 a_2148_n500.t8 VSS.t491 nfet_03v3 ad=4.4p pd=20.88u as=2.6p ps=10.52u w=10u l=0.28u
X238 VSS.t98 E_SENSE_CLK.t3 XFRONT.XFE_E.NTAIL.t1 VSS.t97 nfet_03v3 ad=2.6p pd=10.52u as=2.6p ps=10.52u w=10u l=0.28u
X239 a_n10800_n21572.t0 TERM_EN1_N.t3 VDD.t175 VDD.t174 pfet_03v3 ad=0.88p pd=4.88u as=0.88p ps=4.88u w=2u l=0.28u
X240 VSS.t485 RX_BIAS.t11 a_n5052_2600.t6 VSS.t484 nfet_03v3 ad=0.52p pd=2.52u as=0.52p ps=2.52u w=2u l=0.28u
X241 a_n5052_n1000.t3 RXP.t9 a_n6572_3500.t4 VSS.t383 nfet_03v3 ad=2.6p pd=10.52u as=4.4p ps=20.88u w=10u l=0.28u
X242 XFRONT.XFE_E.NIP.t14 XFRONT.XFE_E.XN.t35 XFRONT.XFE_E.XP.t26 VSS.t148 nfet_03v3 ad=2.08p pd=8.52u as=2.08p ps=8.52u w=8u l=0.28u
X243 XCAP.O_QBUF.t0 XCAP.O_QBI.t14 VSS.t187 VSS.t186 nfet_03v3 ad=1.76p pd=8.88u as=1.04p ps=4.52u w=4u l=0.28u
X244 VSS.t347 XFRONT.XFE_O.H.t19 FE_O_P.t6 VSS.t346 nfet_03v3 ad=2.08p pd=8.52u as=2.08p ps=8.52u w=8u l=0.28u
X245 XCAP.ODD_DB_BUF.t3 FE_O_P.t15 VDD.t159 VDD.t158 pfet_03v3 ad=2.08p pd=8.52u as=2.08p ps=8.52u w=8u l=0.28u
X246 XFRONT.XFE_O.HB.t3 XFRONT.XFE_O.DN.t10 VSS.t364 VSS.t363 nfet_03v3 ad=2.08p pd=8.52u as=2.08p ps=8.52u w=8u l=0.28u
X247 XFRONT.XFE_O.NIP.t23 XFRONT.XFE_O.XN.t43 XFRONT.XFE_O.XP.t31 VSS.t503 nfet_03v3 ad=2.08p pd=8.52u as=3.52p ps=16.88u w=8u l=0.28u
X248 VDD.t181 XFRONT.XFE_E.XN.t47 XFRONT.XFE_E.DN.t5 VDD.t180 pfet_03v3 ad=2.08p pd=8.52u as=2.08p ps=8.52u w=8u l=0.28u
X249 XFRONT.XFE_O.XN.t9 O_SENSE_CLK.t5 VDD.t322 VDD.t321 pfet_03v3 ad=3.52p pd=16.88u as=2.08p ps=8.52u w=8u l=0.28u
X250 XFRONT.XFE_E.NIP.t21 RX_RAWN.t14 XFRONT.XFE_E.NTAIL.t16 VSS.t400 nfet_03v3 ad=2.08p pd=8.52u as=2.08p ps=8.52u w=8u l=0.28u
X251 VSS.t381 XFRONT.XFE_E.HB.t21 FE_E_P.t4 VSS.t380 nfet_03v3 ad=2.08p pd=8.52u as=3.52p ps=16.88u w=8u l=0.28u
X252 VDD.t310 O_SENSE_CLK.t18 XFRONT.XFE_O.NIN.t12 VDD.t309 pfet_03v3 ad=2.08p pd=8.52u as=3.52p ps=16.88u w=8u l=0.28u
X253 a_n7300_n18100.t3 a_n10800_n17972.t3 a_n6400_n18052.t3 VSS.t215 nfet_03v3 ad=4.4p pd=20.88u as=2.6p ps=10.52u w=10u l=0.28u
X254 XFRONT.XFE_E.XN.t3 E_SENSE_CLK.t20 XFRONT.XFE_E.XP.t6 VDD.t99 pfet_03v3 ad=2.08p pd=8.52u as=2.08p ps=8.52u w=8u l=0.28u
X255 VSS.t153 XCAP.O_QBI.t13 XCAP.O_QI.t4 VSS.t152 nfet_03v3 ad=2.08p pd=8.52u as=3.52p ps=16.88u w=8u l=0.28u
X256 a_n6400_n21652.t0 TERM_EN1_N.t0 a_n7157_n21700.t2 VDD.t177 pfet_03v3 ad=2.6p pd=10.52u as=4.4p ps=20.88u w=10u l=0.28u
X257 a_n6400_n21652.t2 RXN.t5 VSS.t322 ppolyf_u r_width=1u r_length=2.43u
X258 XFRONT.XFE_E.XP.t23 XFRONT.XFE_E.XN.t38 XFRONT.XFE_E.NIP.t11 VSS.t119 nfet_03v3 ad=2.08p pd=8.52u as=2.08p ps=8.52u w=8u l=0.28u
X259 XCAP.O_PRST_TAIL.t9 O_CAPTURE_CLKB.t10 VDD.t336 VDD.t335 pfet_03v3 ad=2.08p pd=8.52u as=2.08p ps=8.52u w=8u l=0.28u
X260 XFRONT.XFE_O.DP.t4 XFRONT.XFE_O.XP.t48 VDD.t403 VDD.t402 pfet_03v3 ad=2.08p pd=8.52u as=2.08p ps=8.52u w=8u l=0.28u
X261 VDD.t136 FE_E_N.t16 XCAP.EVEN_D_BUF.t2 VDD.t135 pfet_03v3 ad=2.08p pd=8.52u as=2.08p ps=8.52u w=8u l=0.28u
X262 VSS.t222 O_SENSE_CLK.t2 XFRONT.XFE_O.NTAIL.t2 VSS.t221 nfet_03v3 ad=2.6p pd=10.52u as=2.6p ps=10.52u w=10u l=0.28u
X263 VDD.t264 O_SENSE_CLK.t30 XFRONT.XFE_O.NIP.t9 VDD.t263 pfet_03v3 ad=2.08p pd=8.52u as=3.52p ps=16.88u w=8u l=0.28u
X264 VSS.t414 XCAP.E_QBI.t13 XCAP.E_QI.t11 VSS.t56 nfet_03v3 ad=2.08p pd=8.52u as=3.52p ps=16.88u w=8u l=0.28u
X265 a_n6400_n12652.t2 a_n10800_n12572.t2 a_n7300_n12700.t2 VSS.t211 nfet_03v3 ad=2.6p pd=10.52u as=4.4p ps=20.88u w=10u l=0.28u
X266 XFRONT.XFE_O.NTAIL.t26 O_SENSE_BOOST.t10 VSS.t295 VSS.t294 nfet_03v3 ad=2.6p pd=10.52u as=2.6p ps=10.52u w=10u l=0.28u
X267 XFRONT.XFE_O.NTAIL.t10 RX_RAWP.t11 XFRONT.XFE_O.NIP.t13 VSS.t235 nfet_03v3 ad=2.08p pd=8.52u as=3.52p ps=16.88u w=8u l=0.28u
X268 XFRONT.XFE_O.DN.t3 XFRONT.XFE_O.XN.t44 VSS.t79 VSS.t78 nfet_03v3 ad=3.52p pd=16.88u as=2.08p ps=8.52u w=8u l=0.28u
X269 XCAP.O_QBI.t11 XCAP.ODD_D_BUF.t18 XCAP.O_PRST_TAIL.t3 VDD.t13 pfet_03v3 ad=2.08p pd=8.52u as=2.08p ps=8.52u w=8u l=0.28u
X270 XFRONT.XFE_E.NTAIL.t26 E_SENSE_BOOST.t18 VSS.t440 VSS.t439 nfet_03v3 ad=2.6p pd=10.52u as=2.6p ps=10.52u w=10u l=0.28u
X271 XFRONT.XFE_O.NIN.t15 O_SENSE_CLK.t15 VDD.t312 VDD.t311 pfet_03v3 ad=3.52p pd=16.88u as=2.08p ps=8.52u w=8u l=0.28u
X272 XFRONT.XFE_E.XP.t15 E_SENSE_CLK.t7 VDD.t128 VDD.t127 pfet_03v3 ad=2.08p pd=8.52u as=2.08p ps=8.52u w=8u l=0.28u
X273 XCAP.E_SET_TAIL.t9 E_CAPTURE_CLK.t10 VSS.t60 VSS.t34 nfet_03v3 ad=2.08p pd=8.52u as=2.08p ps=8.52u w=8u l=0.28u
X274 XFRONT.XFE_E.XP.t3 E_SENSE_CLK.t23 XFRONT.XFE_E.XN.t6 VDD.t96 pfet_03v3 ad=2.08p pd=8.52u as=2.08p ps=8.52u w=8u l=0.28u
X275 VSS.t42 XCAP.O_QBUF.t4 ODD_QB.t2 VSS.t41 nfet_03v3 ad=3.52p pd=16.88u as=2.08p ps=8.52u w=8u l=0.28u
X276 XCAP.E_QBI.t2 XCAP.EVEN_D_BUF.t18 XCAP.E_PRST_TAIL.t0 VDD.t3 pfet_03v3 ad=2.08p pd=8.52u as=2.08p ps=8.52u w=8u l=0.28u
X277 XFRONT.XFE_O.H.t14 XFRONT.XFE_O.DP.t8 VSS.t418 VSS.t417 nfet_03v3 ad=2.08p pd=8.52u as=2.08p ps=8.52u w=8u l=0.28u
X278 a_n10800_n16172.t1 TERM_EN4_N.t2 VSS.t324 VSS.t43 nfet_03v3 ad=0.44p pd=2.88u as=0.44p ps=2.88u w=1u l=0.28u
X279 XFRONT.XFE_E.NIN.t10 XFRONT.XFE_E.XP.t33 XFRONT.XFE_E.XN.t26 VSS.t193 nfet_03v3 ad=2.08p pd=8.52u as=2.08p ps=8.52u w=8u l=0.28u
X280 XFRONT.XFE_O.XN.t10 O_SENSE_CLK.t26 XFRONT.XFE_O.XP.t11 VDD.t287 pfet_03v3 ad=2.08p pd=8.52u as=3.52p ps=16.88u w=8u l=0.28u
X281 VDD.t425 FE_E_P.t12 XCAP.EVEN_DB_BUF.t6 VDD.t424 pfet_03v3 ad=2.08p pd=8.52u as=2.08p ps=8.52u w=8u l=0.28u
X282 VSS.t157 XCAP.E_QBBUF.t6 EVEN_Q.t2 VSS.t156 nfet_03v3 ad=2.08p pd=8.52u as=3.52p ps=16.88u w=8u l=0.28u
X283 VSS.t444 E_SENSE_BOOST.t21 XFRONT.XFE_E.NTAIL.t23 VSS.t443 nfet_03v3 ad=2.6p pd=10.52u as=2.6p ps=10.52u w=10u l=0.28u
X284 XFRONT.XFE_E.XP.t29 XFRONT.XFE_E.XN.t32 XFRONT.XFE_E.NIP.t4 VSS.t31 nfet_03v3 ad=3.52p pd=16.88u as=2.08p ps=8.52u w=8u l=0.28u
X285 XFRONT.XFE_O.H.t3 XFRONT.XFE_O.HB.t27 VDD.t470 VDD.t469 pfet_03v3 ad=2.08p pd=8.52u as=2.08p ps=8.52u w=8u l=0.28u
X286 XFRONT.XFE_O.XN.t27 XFRONT.XFE_O.XP.t34 XFRONT.XFE_O.NIN.t8 VSS.t76 nfet_03v3 ad=2.08p pd=8.52u as=2.08p ps=8.52u w=8u l=0.28u
X287 VDD.t375 XFRONT.XFE_O.H.t26 FE_O_P.t2 VDD.t374 pfet_03v3 ad=3.52p pd=16.88u as=2.08p ps=8.52u w=8u l=0.28u
X288 VDD.t68 E_SENSE_CLK.t40 XFRONT.XFE_E.XN.t7 VDD.t67 pfet_03v3 ad=2.08p pd=8.52u as=3.52p ps=16.88u w=8u l=0.28u
X289 XFRONT.XFE_O.NIP.t6 XFRONT.XFE_O.XN.t35 XFRONT.XFE_O.XP.t6 VSS.t183 nfet_03v3 ad=2.08p pd=8.52u as=2.08p ps=8.52u w=8u l=0.28u
X290 XFRONT.XFE_E.H.t14 XFRONT.XFE_E.XN.t52 VDD.t385 VDD.t384 pfet_03v3 ad=2.08p pd=8.52u as=2.08p ps=8.52u w=8u l=0.28u
X291 XFRONT.XFE_O.NTAIL.t20 O_SENSE_BOOST.t16 VSS.t285 VSS.t284 nfet_03v3 ad=2.6p pd=10.52u as=2.6p ps=10.52u w=10u l=0.28u
X292 VSS.t510 XFRONT.XFE_E.DP.t9 XFRONT.XFE_E.H.t8 VSS.t509 nfet_03v3 ad=2.08p pd=8.52u as=2.08p ps=8.52u w=8u l=0.28u
X293 XCAP.O_PSET_TAIL.t0 XCAP.ODD_DB_BUF.t17 XCAP.O_QI.t0 VDD.t12 pfet_03v3 ad=2.08p pd=8.52u as=2.08p ps=8.52u w=8u l=0.28u
X294 FE_E_P.t0 XFRONT.XFE_E.HB.t18 VSS.t130 VSS.t129 nfet_03v3 ad=3.52p pd=16.88u as=2.08p ps=8.52u w=8u l=0.28u
X295 a_2148_n500.t0 a_n3600_5641.t7 RX_RAWN.t0 VSS.t82 nfet_03v3 ad=1.3p pd=5.52u as=2.2p ps=10.88u w=5u l=0.28u
X296 XCAP.EVEN_DB_BUF.t3 FE_E_P.t15 VDD.t419 VDD.t418 pfet_03v3 ad=2.08p pd=8.52u as=2.08p ps=8.52u w=8u l=0.28u
X297 XCAP.E_PRST_TAIL.t9 E_CAPTURE_CLKB.t10 VDD.t252 VDD.t251 pfet_03v3 ad=2.08p pd=8.52u as=2.08p ps=8.52u w=8u l=0.28u
X298 VSS.t88 FE_O_N.t10 XCAP.ODD_D_BUF.t8 VSS.t87 nfet_03v3 ad=2.08p pd=8.52u as=3.52p ps=16.88u w=8u l=0.28u
X299 a_n10800_n19772.t1 TERM_EN2_N.t2 VSS.t132 VSS.t43 nfet_03v3 ad=0.44p pd=2.88u as=0.44p ps=2.88u w=1u l=0.28u
X300 XFRONT.XFE_E.NTAIL.t12 RX_RAWP.t17 XFRONT.XFE_E.NIN.t15 VSS.t229 nfet_03v3 ad=2.08p pd=8.52u as=2.08p ps=8.52u w=8u l=0.28u
X301 VSS.t28 XFRONT.XFE_E.XN.t45 XFRONT.XFE_E.DN.t1 VSS.t27 nfet_03v3 ad=2.08p pd=8.52u as=3.52p ps=16.88u w=8u l=0.28u
X302 VDD.t326 O_CAPTURE_CLKB.t13 XCAP.O_PRST_TAIL.t6 VDD.t325 pfet_03v3 ad=2.08p pd=8.52u as=2.08p ps=8.52u w=8u l=0.28u
X303 XFRONT.XFE_E.NTAIL.t42 E_SENSE_BOOST.t2 VSS.t478 VSS.t477 nfet_03v3 ad=2.6p pd=10.52u as=2.6p ps=10.52u w=10u l=0.28u
X304 XCAP.EVEN_D_BUF.t5 FE_E_N.t13 VDD.t142 VDD.t141 pfet_03v3 ad=2.08p pd=8.52u as=2.08p ps=8.52u w=8u l=0.28u
X305 XFRONT.XFE_O.H.t1 XFRONT.XFE_O.XN.t54 VDD.t222 VDD.t221 pfet_03v3 ad=2.08p pd=8.52u as=2.08p ps=8.52u w=8u l=0.28u
X306 XFRONT.XFE_O.HB.t16 XFRONT.XFE_O.XP.t52 VDD.t438 VDD.t437 pfet_03v3 ad=2.08p pd=8.52u as=2.08p ps=8.52u w=8u l=0.28u
X307 XFRONT.XFE_O.XP.t0 XFRONT.XFE_O.XN.t32 XFRONT.XFE_O.NIP.t0 VSS.t20 nfet_03v3 ad=3.52p pd=16.88u as=2.08p ps=8.52u w=8u l=0.28u
X308 XCAP.ODD_DB_BUF.t11 FE_O_P.t7 VSS.t140 VSS.t139 nfet_03v3 ad=3.52p pd=16.88u as=2.08p ps=8.52u w=8u l=0.28u
X309 XCAP.O_QBI.t0 XCAP.ODD_D_BUF.t12 XCAP.O_SET_TAIL.t0 VSS.t23 nfet_03v3 ad=3.52p pd=16.88u as=2.08p ps=8.52u w=8u l=0.28u
X310 VSS.t291 O_SENSE_BOOST.t13 XFRONT.XFE_O.NTAIL.t23 VSS.t290 nfet_03v3 ad=2.6p pd=10.52u as=2.6p ps=10.52u w=10u l=0.28u
X311 VSS.t438 E_SENSE_BOOST.t15 XFRONT.XFE_E.NTAIL.t29 VSS.t437 nfet_03v3 ad=2.6p pd=10.52u as=2.6p ps=10.52u w=10u l=0.28u
X312 XFRONT.XFE_E.H.t5 XFRONT.XFE_E.DP.t12 VSS.t500 VSS.t499 nfet_03v3 ad=2.08p pd=8.52u as=2.08p ps=8.52u w=8u l=0.28u
X313 XFRONT.XFE_O.XN.t21 XFRONT.XFE_O.XP.t40 XFRONT.XFE_O.NIN.t2 VSS.t8 nfet_03v3 ad=2.08p pd=8.52u as=2.08p ps=8.52u w=8u l=0.28u
X314 VSS.t62 E_CAPTURE_CLK.t9 XCAP.E_SET_TAIL.t10 VSS.t61 nfet_03v3 ad=2.08p pd=8.52u as=2.08p ps=8.52u w=8u l=0.28u
X315 a_n6400_n16252.t1 a_n10800_n16172.t2 a_n7300_n16300.t0 VSS.t164 nfet_03v3 ad=2.6p pd=10.52u as=4.4p ps=20.88u w=10u l=0.28u
X316 VDD.t340 O_CAPTURE_CLKB.t7 XCAP.O_PSET_TAIL.t4 VDD.t327 pfet_03v3 ad=2.08p pd=8.52u as=3.52p ps=16.88u w=8u l=0.28u
X317 XCAP.O_SET_TAIL.t7 O_CAPTURE_CLK.t12 VSS.t250 VSS.t152 nfet_03v3 ad=2.08p pd=8.52u as=2.08p ps=8.52u w=8u l=0.28u
X318 VDD.t80 E_SENSE_CLK.t34 XFRONT.XFE_E.XN.t13 VDD.t79 pfet_03v3 ad=2.08p pd=8.52u as=2.08p ps=8.52u w=8u l=0.28u
X319 ODD_Q.t1 XCAP.O_QBBUF.t7 VDD.t5 VDD.t4 pfet_03v3 ad=3.52p pd=16.88u as=2.08p ps=8.52u w=8u l=0.28u
X320 VDD.t401 XFRONT.XFE_O.XP.t47 XFRONT.XFE_O.DP.t3 VDD.t400 pfet_03v3 ad=2.08p pd=8.52u as=2.08p ps=8.52u w=8u l=0.28u
X321 XCAP.ODD_D_BUF.t11 FE_O_N.t7 VSS.t90 VSS.t89 nfet_03v3 ad=3.52p pd=16.88u as=2.08p ps=8.52u w=8u l=0.28u
X322 XFRONT.XFE_O.NTAIL.t14 O_SENSE_BOOST.t22 VSS.t273 VSS.t272 nfet_03v3 ad=2.6p pd=10.52u as=2.6p ps=10.52u w=10u l=0.28u
X323 VSS.t377 XFRONT.XFE_O.DP.t11 XFRONT.XFE_O.H.t11 VSS.t376 nfet_03v3 ad=2.08p pd=8.52u as=2.08p ps=8.52u w=8u l=0.28u
X324 XCAP.E_SET_TAIL.t7 E_CAPTURE_CLK.t12 VSS.t57 VSS.t56 nfet_03v3 ad=2.08p pd=8.52u as=2.08p ps=8.52u w=8u l=0.28u
X325 XFRONT.XFE_E.HB.t16 XFRONT.XFE_E.H.t21 VSS.t433 VSS.t432 nfet_03v3 ad=3.52p pd=16.88u as=3.52p ps=16.88u w=8u l=0.28u
X326 XFRONT.XFE_E.HB.t10 XFRONT.XFE_E.DN.t6 VSS.t199 VSS.t198 nfet_03v3 ad=3.52p pd=16.88u as=2.08p ps=8.52u w=8u l=0.28u
X327 RXP.t0 a_n7157_n21700.t0 VSS.t115 ppolyf_u r_width=1u r_length=2.43u
X328 XFRONT.XFE_O.NIN.t5 XFRONT.XFE_O.XP.t37 XFRONT.XFE_O.XN.t24 VSS.t47 nfet_03v3 ad=2.08p pd=8.52u as=2.08p ps=8.52u w=8u l=0.28u
X329 RXP.t5 RXN.t7 VSS.t385 ppolyf_u r_width=4u r_length=1.23u
X330 XFRONT.XFE_O.XN.t1 O_SENSE_CLK.t13 VDD.t300 VDD.t299 pfet_03v3 ad=2.08p pd=8.52u as=2.08p ps=8.52u w=8u l=0.28u
X331 XFRONT.XFE_O.NTAIL.t43 RX_RAWN.t7 XFRONT.XFE_O.NIN.t20 VSS.t407 nfet_03v3 ad=2.08p pd=8.52u as=2.08p ps=8.52u w=8u l=0.28u
X332 VSS.t254 O_CAPTURE_CLK.t9 XCAP.O_SET_TAIL.t10 VSS.t253 nfet_03v3 ad=2.08p pd=8.52u as=2.08p ps=8.52u w=8u l=0.28u
X333 XFRONT.XFE_E.XN.t10 E_SENSE_CLK.t37 VDD.t76 VDD.t75 pfet_03v3 ad=2.08p pd=8.52u as=2.08p ps=8.52u w=8u l=0.28u
X334 XFRONT.XFE_O.XP.t3 XFRONT.XFE_O.XN.t38 XFRONT.XFE_O.NIP.t3 VSS.t161 nfet_03v3 ad=2.08p pd=8.52u as=2.08p ps=8.52u w=8u l=0.28u
X335 VDD.t266 O_SENSE_CLK.t28 XFRONT.XFE_O.NIP.t11 VDD.t265 pfet_03v3 ad=2.08p pd=8.52u as=2.08p ps=8.52u w=8u l=0.28u
X336 VSS.t269 O_SENSE_BOOST.t19 XFRONT.XFE_O.NTAIL.t17 VSS.t268 nfet_03v3 ad=2.6p pd=10.52u as=2.6p ps=10.52u w=10u l=0.28u
X337 VDD.t43 XCAP.E_QBI.t19 XCAP.E_QBUF.t0 VDD.t42 pfet_03v3 ad=2.08p pd=8.52u as=3.52p ps=16.88u w=8u l=0.28u
X338 XFRONT.XFE_E.XP.t13 E_SENSE_CLK.t9 VDD.t122 VDD.t121 pfet_03v3 ad=2.08p pd=8.52u as=2.08p ps=8.52u w=8u l=0.28u
X339 a_n6400_n19852.t3 a_n10800_n19772.t2 a_n7300_n19900.t2 VSS.t365 nfet_03v3 ad=2.6p pd=10.52u as=4.4p ps=20.88u w=10u l=0.28u
X340 XFRONT.XFE_E.NTAIL.t17 RX_RAWN.t19 XFRONT.XFE_E.NIP.t16 VSS.t395 nfet_03v3 ad=2.08p pd=8.52u as=3.52p ps=16.88u w=8u l=0.28u
X341 XCAP.EVEN_DB_BUF.t11 FE_E_P.t7 VSS.t393 VSS.t392 nfet_03v3 ad=3.52p pd=16.88u as=2.08p ps=8.52u w=8u l=0.28u
X342 XCAP.O_RST_TAIL.t1 XCAP.ODD_DB_BUF.t13 XCAP.O_QI.t7 VSS.t150 nfet_03v3 ad=2.08p pd=8.52u as=2.08p ps=8.52u w=8u l=0.28u
X343 FE_E_P.t1 XFRONT.XFE_E.HB.t26 VDD.t199 VDD.t198 pfet_03v3 ad=3.52p pd=16.88u as=2.08p ps=8.52u w=8u l=0.28u
X344 VDD.t248 E_CAPTURE_CLKB.t13 XCAP.E_PRST_TAIL.t6 VDD.t237 pfet_03v3 ad=2.08p pd=8.52u as=2.08p ps=8.52u w=8u l=0.28u
X345 XFRONT.XFE_E.NIP.t3 XFRONT.XFE_E.XN.t43 XFRONT.XFE_E.XP.t18 VSS.t24 nfet_03v3 ad=2.08p pd=8.52u as=3.52p ps=16.88u w=8u l=0.28u
X346 a_n7157_n23500.t2 a_n10800_n23372.t3 a_n6400_n23452.t2 VSS.t371 nfet_03v3 ad=4.4p pd=20.88u as=2.6p ps=10.52u w=10u l=0.28u
X347 a_n10800_n21572.t1 TERM_EN1_N.t2 VSS.t143 VSS.t43 nfet_03v3 ad=0.44p pd=2.88u as=0.44p ps=2.88u w=1u l=0.28u
X348 XFRONT.XFE_O.NIN.t23 RX_RAWN.t4 XFRONT.XFE_O.NTAIL.t42 VSS.t410 nfet_03v3 ad=3.52p pd=16.88u as=2.08p ps=8.52u w=8u l=0.28u
X349 XFRONT.XFE_E.NIN.t18 RX_RAWP.t14 XFRONT.XFE_E.NTAIL.t7 VSS.t232 nfet_03v3 ad=2.08p pd=8.52u as=2.08p ps=8.52u w=8u l=0.28u
X350 XCAP.E_QBI.t0 XCAP.EVEN_D_BUF.t12 XCAP.E_SET_TAIL.t0 VSS.t16 nfet_03v3 ad=3.52p pd=16.88u as=2.08p ps=8.52u w=8u l=0.28u
X351 VSS.t493 RX_BIAS.t5 a_n5052_n1000.t8 VSS.t491 nfet_03v3 ad=4.4p pd=20.88u as=2.6p ps=10.52u w=10u l=0.28u
X352 XFRONT.XFE_E.NIN.t12 XFRONT.XFE_E.XP.t35 XFRONT.XFE_E.XN.t28 VSS.t195 nfet_03v3 ad=2.08p pd=8.52u as=2.08p ps=8.52u w=8u l=0.28u
X353 FE_E_N.t4 XFRONT.XFE_E.H.t19 VSS.t429 VSS.t428 nfet_03v3 ad=2.08p pd=8.52u as=2.08p ps=8.52u w=8u l=0.28u
X354 XCAP.O_QI.t9 XCAP.O_QBI.t16 VDD.t200 VDD.t12 pfet_03v3 ad=3.52p pd=16.88u as=2.08p ps=8.52u w=8u l=0.28u
X355 VSS.t134 FE_O_P.t10 XCAP.ODD_DB_BUF.t8 VSS.t133 nfet_03v3 ad=2.08p pd=8.52u as=3.52p ps=16.88u w=8u l=0.28u
X356 a_n7300_n12700.t0 TERM_EN6_N.t1 a_n6400_n12652.t0 VDD.t29 pfet_03v3 ad=4.4p pd=20.88u as=2.6p ps=10.52u w=10u l=0.28u
X357 XFRONT.XFE_O.NIP.t18 RX_RAWP.t6 XFRONT.XFE_O.NTAIL.t8 VSS.t240 nfet_03v3 ad=2.08p pd=8.52u as=2.08p ps=8.52u w=8u l=0.28u
X358 VSS.t436 E_SENSE_BOOST.t23 XFRONT.XFE_E.NTAIL.t21 VSS.t435 nfet_03v3 ad=2.6p pd=10.52u as=4.4p ps=20.88u w=10u l=0.28u
X359 XCAP.O_SET_TAIL.t1 XCAP.ODD_D_BUF.t15 XCAP.O_QBI.t5 VSS.t83 nfet_03v3 ad=2.08p pd=8.52u as=3.52p ps=16.88u w=8u l=0.28u
X360 XFRONT.XFE_O.XN.t31 XFRONT.XFE_O.XP.t54 VDD.t205 VDD.t204 pfet_03v3 ad=3.52p pd=16.88u as=2.08p ps=8.52u w=8u l=0.28u
X361 VDD.t456 XFRONT.XFE_E.H.t28 XFRONT.XFE_E.HB.t12 VDD.t455 pfet_03v3 ad=2.08p pd=8.52u as=3.52p ps=16.88u w=8u l=0.28u
X362 VDD.t110 E_SENSE_CLK.t12 XFRONT.XFE_E.XP.t10 VDD.t109 pfet_03v3 ad=2.08p pd=8.52u as=2.08p ps=8.52u w=8u l=0.28u
X363 VDD.t246 E_CAPTURE_CLKB.t7 XCAP.E_PSET_TAIL.t4 VDD.t245 pfet_03v3 ad=2.08p pd=8.52u as=3.52p ps=16.88u w=8u l=0.28u
X364 VSS.t189 XCAP.O_QBI.t15 XCAP.O_QBUF.t1 VSS.t188 nfet_03v3 ad=1.04p pd=4.52u as=1.76p ps=8.88u w=4u l=0.28u
X365 a_n5052_n1000.t1 RXN.t9 a_n3600_5641.t0 VSS.t82 nfet_03v3 ad=2.6p pd=10.52u as=4.4p ps=20.88u w=10u l=0.28u
X366 VSS.t387 FE_E_P.t10 XCAP.EVEN_DB_BUF.t8 VSS.t386 nfet_03v3 ad=2.08p pd=8.52u as=3.52p ps=16.88u w=8u l=0.28u
X367 FE_O_P.t3 XFRONT.XFE_O.H.t20 VSS.t339 VSS.t338 nfet_03v3 ad=2.08p pd=8.52u as=2.08p ps=8.52u w=8u l=0.28u
X368 XFRONT.XFE_O.NIN.t11 XFRONT.XFE_O.XP.t43 XFRONT.XFE_O.XN.t18 VSS.t146 nfet_03v3 ad=2.08p pd=8.52u as=3.52p ps=16.88u w=8u l=0.28u
X369 VDD.t216 XCAP.O_QBBUF.t10 ODD_Q.t5 VDD.t215 pfet_03v3 ad=2.08p pd=8.52u as=3.52p ps=16.88u w=8u l=0.28u
X370 XCAP.E_QI.t7 XCAP.EVEN_DB_BUF.t16 XCAP.E_PSET_TAIL.t2 VDD.t24 pfet_03v3 ad=3.52p pd=16.88u as=2.08p ps=8.52u w=8u l=0.28u
X371 VSS.t258 O_CAPTURE_CLK.t7 XCAP.O_RST_TAIL.t4 VSS.t257 nfet_03v3 ad=2.08p pd=8.52u as=3.52p ps=16.88u w=8u l=0.28u
X372 XFRONT.XFE_O.XP.t19 O_SENSE_CLK.t37 VDD.t276 VDD.t275 pfet_03v3 ad=2.08p pd=8.52u as=2.08p ps=8.52u w=8u l=0.28u
X373 XCAP.O_QBI.t4 XCAP.O_QI.t12 VSS.t36 VSS.t35 nfet_03v3 ad=3.52p pd=16.88u as=2.08p ps=8.52u w=8u l=0.28u
X374 XCAP.O_QBUF.t2 XCAP.O_QBI.t18 VDD.t430 VDD.t429 pfet_03v3 ad=3.52p pd=16.88u as=2.08p ps=8.52u w=8u l=0.28u
X375 XFRONT.XFE_E.XN.t25 XFRONT.XFE_E.XP.t38 XFRONT.XFE_E.NIN.t9 VSS.t173 nfet_03v3 ad=2.08p pd=8.52u as=2.08p ps=8.52u w=8u l=0.28u
X376 XFRONT.XFE_O.XP.t26 O_SENSE_CLK.t21 XFRONT.XFE_O.XN.t15 VDD.t292 pfet_03v3 ad=2.08p pd=8.52u as=2.08p ps=8.52u w=8u l=0.28u
X377 XCAP.EVEN_DB_BUF.t1 FE_E_P.t17 VDD.t411 VDD.t410 pfet_03v3 ad=2.08p pd=8.52u as=2.08p ps=8.52u w=8u l=0.28u
X378 XCAP.EVEN_D_BUF.t9 FE_E_N.t9 VSS.t112 VSS.t111 nfet_03v3 ad=2.08p pd=8.52u as=2.08p ps=8.52u w=8u l=0.28u
X379 XFRONT.XFE_E.NIP.t10 XFRONT.XFE_E.XN.t37 XFRONT.XFE_E.XP.t24 VSS.t118 nfet_03v3 ad=2.08p pd=8.52u as=2.08p ps=8.52u w=8u l=0.28u
X380 XFRONT.XFE_E.NTAIL.t40 E_SENSE_BOOST.t4 VSS.t474 VSS.t473 nfet_03v3 ad=2.6p pd=10.52u as=2.6p ps=10.52u w=10u l=0.28u
X381 VDD.t332 O_CAPTURE_CLKB.t11 XCAP.O_PRST_TAIL.t8 VDD.t331 pfet_03v3 ad=2.08p pd=8.52u as=2.08p ps=8.52u w=8u l=0.28u
X382 VSS.t160 XCAP.E_QI.t15 XCAP.E_QBBUF.t2 VSS.t111 nfet_03v3 ad=1.04p pd=4.52u as=1.76p ps=8.88u w=4u l=0.28u
X383 XFRONT.XFE_O.NIN.t17 RX_RAWN.t10 XFRONT.XFE_O.NTAIL.t37 VSS.t404 nfet_03v3 ad=2.08p pd=8.52u as=2.08p ps=8.52u w=8u l=0.28u
X384 a_n6400_n14452.t0 RXN.t1 VSS.t116 ppolyf_u r_width=1u r_length=1u
X385 XCAP.E_QI.t9 XCAP.E_QBI.t12 VSS.t320 VSS.t58 nfet_03v3 ad=3.52p pd=16.88u as=2.08p ps=8.52u w=8u l=0.28u
X386 VDD.t148 XFRONT.XFE_E.XN.t49 XFRONT.XFE_E.DN.t3 VDD.t147 pfet_03v3 ad=2.08p pd=8.52u as=3.52p ps=16.88u w=8u l=0.28u
X387 VSS.t81 XFRONT.XFE_O.XN.t45 XFRONT.XFE_O.DN.t4 VSS.t80 nfet_03v3 ad=2.08p pd=8.52u as=3.52p ps=16.88u w=8u l=0.28u
X388 VSS.t335 XFRONT.XFE_O.HB.t20 FE_O_N.t6 VSS.t334 nfet_03v3 ad=2.08p pd=8.52u as=3.52p ps=16.88u w=8u l=0.28u
X389 a_n6400_n21652.t3 a_n10800_n21572.t2 a_n7157_n21700.t3 VSS.t327 nfet_03v3 ad=2.6p pd=10.52u as=4.4p ps=20.88u w=10u l=0.28u
X390 VDD.t280 O_SENSE_CLK.t34 XFRONT.XFE_O.XP.t22 VDD.t279 pfet_03v3 ad=2.08p pd=8.52u as=2.08p ps=8.52u w=8u l=0.28u
X391 VDD.t124 E_SENSE_CLK.t6 XFRONT.XFE_E.XP.t16 VDD.t123 pfet_03v3 ad=2.08p pd=8.52u as=2.08p ps=8.52u w=8u l=0.28u
X392 VDD.t308 O_SENSE_CLK.t16 XFRONT.XFE_O.NIN.t14 VDD.t307 pfet_03v3 ad=2.08p pd=8.52u as=2.08p ps=8.52u w=8u l=0.28u
X393 VSS.t329 XFRONT.XFE_E.DN.t7 XFRONT.XFE_E.HB.t9 VSS.t328 nfet_03v3 ad=2.08p pd=8.52u as=2.08p ps=8.52u w=8u l=0.28u
X394 VDD.t206 a_n6572_3500.t2 VSS.t180 ppolyf_u r_width=2u r_length=4.57u
X395 XFRONT.XFE_E.XN.t19 E_SENSE_CLK.t22 XFRONT.XFE_E.XP.t4 VDD.t97 pfet_03v3 ad=2.08p pd=8.52u as=2.08p ps=8.52u w=8u l=0.28u
X396 XFRONT.XFE_O.XP.t25 O_SENSE_CLK.t31 VDD.t282 VDD.t281 pfet_03v3 ad=3.52p pd=16.88u as=2.08p ps=8.52u w=8u l=0.28u
X397 XCAP.E_PRST_TAIL.t3 XCAP.EVEN_D_BUF.t17 XCAP.E_QBI.t11 VDD.t2 pfet_03v3 ad=2.08p pd=8.52u as=2.08p ps=8.52u w=8u l=0.28u
X398 XFRONT.XFE_E.XP.t21 XFRONT.XFE_E.XN.t40 XFRONT.XFE_E.NIP.t0 VSS.t13 nfet_03v3 ad=2.08p pd=8.52u as=2.08p ps=8.52u w=8u l=0.28u
X399 VDD.t227 a_5300_5958.t0 VSS.t205 ppolyf_u r_width=1u r_length=1.4u
X400 VSS.t468 E_SENSE_BOOST.t7 XFRONT.XFE_E.NTAIL.t37 VSS.t467 nfet_03v3 ad=2.6p pd=10.52u as=2.6p ps=10.52u w=10u l=0.28u
X401 XCAP.O_PRST_TAIL.t11 O_CAPTURE_CLKB.t8 VDD.t334 VDD.t333 pfet_03v3 ad=3.52p pd=16.88u as=2.08p ps=8.52u w=8u l=0.28u
X402 VDD.t140 FE_E_N.t18 XCAP.EVEN_D_BUF.t0 VDD.t139 pfet_03v3 ad=2.08p pd=8.52u as=3.52p ps=16.88u w=8u l=0.28u
X403 XCAP.E_SET_TAIL.t3 XCAP.EVEN_D_BUF.t15 XCAP.E_QBI.t9 VSS.t30 nfet_03v3 ad=2.08p pd=8.52u as=3.52p ps=16.88u w=8u l=0.28u
X404 VSS.t226 O_SENSE_CLK.t0 XFRONT.XFE_O.NTAIL.t4 VSS.t225 nfet_03v3 ad=4.4p pd=20.88u as=2.6p ps=10.52u w=10u l=0.28u
X405 XFRONT.XFE_O.NTAIL.t28 O_SENSE_BOOST.t8 VSS.t299 VSS.t298 nfet_03v3 ad=2.6p pd=10.52u as=2.6p ps=10.52u w=10u l=0.28u
X406 XFRONT.XFE_E.XN.t2 XFRONT.XFE_E.XP.t32 XFRONT.XFE_E.NIN.t0 VSS.t91 nfet_03v3 ad=3.52p pd=16.88u as=2.08p ps=8.52u w=8u l=0.28u
X407 XCAP.EVEN_DB_BUF.t7 FE_E_P.t11 VDD.t423 VDD.t422 pfet_03v3 ad=3.52p pd=16.88u as=2.08p ps=8.52u w=8u l=0.28u
X408 XFRONT.XFE_O.NTAIL.t12 RX_RAWP.t9 XFRONT.XFE_O.NIP.t15 VSS.t237 nfet_03v3 ad=2.08p pd=8.52u as=2.08p ps=8.52u w=8u l=0.28u
X409 FE_O_N.t3 XFRONT.XFE_O.HB.t17 VSS.t319 VSS.t318 nfet_03v3 ad=3.52p pd=16.88u as=2.08p ps=8.52u w=8u l=0.28u
X410 XFRONT.XFE_E.NTAIL.t24 E_SENSE_BOOST.t20 VSS.t446 VSS.t445 nfet_03v3 ad=2.6p pd=10.52u as=2.6p ps=10.52u w=10u l=0.28u
X411 XFRONT.XFE_E.HB.t15 XFRONT.XFE_E.H.t25 VDD.t444 VDD.t443 pfet_03v3 ad=3.52p pd=16.88u as=2.08p ps=8.52u w=8u l=0.28u
X412 VSS.t93 XCAP.O_QBBUF.t6 ODD_Q.t2 VSS.t92 nfet_03v3 ad=2.08p pd=8.52u as=3.52p ps=16.88u w=8u l=0.28u
X413 XFRONT.XFE_O.NIN.t3 XFRONT.XFE_O.XP.t35 XFRONT.XFE_O.XN.t26 VSS.t45 nfet_03v3 ad=2.08p pd=8.52u as=2.08p ps=8.52u w=8u l=0.28u
X414 XFRONT.XFE_E.HB.t6 XFRONT.XFE_E.DN.t10 VSS.t126 VSS.t125 nfet_03v3 ad=2.08p pd=8.52u as=2.08p ps=8.52u w=8u l=0.28u
X415 FE_O_P.t0 XFRONT.XFE_O.H.t27 VDD.t191 VDD.t190 pfet_03v3 ad=2.08p pd=8.52u as=2.08p ps=8.52u w=8u l=0.28u
X416 VSS.t50 E_CAPTURE_CLK.t7 XCAP.E_RST_TAIL.t2 VSS.t49 nfet_03v3 ad=2.08p pd=8.52u as=3.52p ps=16.88u w=8u l=0.28u
X417 XFRONT.XFE_E.XN.t8 E_SENSE_CLK.t39 VDD.t74 VDD.t73 pfet_03v3 ad=2.08p pd=8.52u as=2.08p ps=8.52u w=8u l=0.28u
X418 XCAP.O_PSET_TAIL.t9 O_CAPTURE_CLKB.t2 VDD.t345 VDD.t335 pfet_03v3 ad=2.08p pd=8.52u as=2.08p ps=8.52u w=8u l=0.28u
X419 XFRONT.XFE_O.XP.t27 XFRONT.XFE_O.XN.t50 VDD.t395 VDD.t394 pfet_03v3 ad=3.52p pd=16.88u as=2.08p ps=8.52u w=8u l=0.28u
X420 XFRONT.XFE_E.XP.t1 E_SENSE_CLK.t25 XFRONT.XFE_E.XN.t18 VDD.t94 pfet_03v3 ad=2.08p pd=8.52u as=2.08p ps=8.52u w=8u l=0.28u
X421 a_n7300_n16300.t3 TERM_EN4_N.t1 a_n6400_n16252.t4 VDD.t367 pfet_03v3 ad=4.4p pd=20.88u as=2.6p ps=10.52u w=10u l=0.28u
X422 XCAP.E_QBI.t7 XCAP.E_QI.t12 VSS.t155 VSS.t17 nfet_03v3 ad=3.52p pd=16.88u as=2.08p ps=8.52u w=8u l=0.28u
X423 VDD.t18 XFRONT.XFE_E.XP.t53 XFRONT.XFE_E.HB.t0 VDD.t17 pfet_03v3 ad=2.08p pd=8.52u as=2.08p ps=8.52u w=8u l=0.28u
X424 VDD.t383 XFRONT.XFE_E.XN.t51 XFRONT.XFE_E.H.t13 VDD.t382 pfet_03v3 ad=2.08p pd=8.52u as=2.08p ps=8.52u w=8u l=0.28u
X425 XCAP.E_QI.t3 XCAP.EVEN_DB_BUF.t12 XCAP.E_RST_TAIL.t1 VSS.t34 nfet_03v3 ad=3.52p pd=16.88u as=2.08p ps=8.52u w=8u l=0.28u
X426 XCAP.O_QI.t1 XCAP.ODD_DB_BUF.t18 XCAP.O_PSET_TAIL.t1 VDD.t13 pfet_03v3 ad=2.08p pd=8.52u as=2.08p ps=8.52u w=8u l=0.28u
X427 XFRONT.XFE_O.H.t16 XFRONT.XFE_O.DP.t6 VSS.t168 VSS.t167 nfet_03v3 ad=3.52p pd=16.88u as=2.08p ps=8.52u w=8u l=0.28u
X428 XFRONT.XFE_E.H.t9 XFRONT.XFE_E.DP.t8 VSS.t353 VSS.t352 nfet_03v3 ad=2.08p pd=8.52u as=2.08p ps=8.52u w=8u l=0.28u
X429 ODD_QB.t6 XCAP.O_QBUF.t9 VDD.t232 VDD.t231 pfet_03v3 ad=2.08p pd=8.52u as=2.08p ps=8.52u w=8u l=0.28u
X430 VDD.t274 O_SENSE_CLK.t40 XFRONT.XFE_O.XP.t16 VDD.t273 pfet_03v3 ad=2.08p pd=8.52u as=3.52p ps=16.88u w=8u l=0.28u
X431 FE_E_P.t6 XFRONT.XFE_E.HB.t28 VDD.t462 VDD.t461 pfet_03v3 ad=2.08p pd=8.52u as=3.52p ps=16.88u w=8u l=0.28u
X432 VDD.t155 FE_O_P.t18 XCAP.ODD_DB_BUF.t0 VDD.t154 pfet_03v3 ad=2.08p pd=8.52u as=3.52p ps=16.88u w=8u l=0.28u
X433 VSS.t368 XFRONT.XFE_O.DN.t13 XFRONT.XFE_O.HB.t0 VSS.t367 nfet_03v3 ad=2.08p pd=8.52u as=3.52p ps=16.88u w=8u l=0.28u
X434 VSS.t337 XFRONT.XFE_O.HB.t21 XFRONT.XFE_O.H.t6 VSS.t336 nfet_03v3 ad=3.52p pd=16.88u as=3.52p ps=16.88u w=8u l=0.28u
X435 VSS.t311 O_SENSE_BOOST.t5 XFRONT.XFE_O.NTAIL.t31 VSS.t310 nfet_03v3 ad=2.6p pd=10.52u as=2.6p ps=10.52u w=10u l=0.28u
X436 XFRONT.XFE_O.XN.t12 O_SENSE_CLK.t24 XFRONT.XFE_O.XP.t13 VDD.t289 pfet_03v3 ad=2.08p pd=8.52u as=2.08p ps=8.52u w=8u l=0.28u
X437 VDD.t247 E_CAPTURE_CLKB.t11 XCAP.E_PRST_TAIL.t8 VDD.t188 pfet_03v3 ad=2.08p pd=8.52u as=2.08p ps=8.52u w=8u l=0.28u
X438 VDD.t413 FE_E_P.t14 XCAP.EVEN_DB_BUF.t4 VDD.t412 pfet_03v3 ad=2.08p pd=8.52u as=2.08p ps=8.52u w=8u l=0.28u
X439 XCAP.E_QI.t5 XCAP.EVEN_DB_BUF.t18 XCAP.E_PSET_TAIL.t1 VDD.t3 pfet_03v3 ad=2.08p pd=8.52u as=2.08p ps=8.52u w=8u l=0.28u
X440 XFRONT.XFE_E.XP.t27 XFRONT.XFE_E.XN.t34 XFRONT.XFE_E.NIP.t13 VSS.t147 nfet_03v3 ad=2.08p pd=8.52u as=2.08p ps=8.52u w=8u l=0.28u
X441 XFRONT.XFE_O.XN.t29 XFRONT.XFE_O.XP.t32 XFRONT.XFE_O.NIN.t6 VSS.t74 nfet_03v3 ad=3.52p pd=16.88u as=2.08p ps=8.52u w=8u l=0.28u
X442 a_n10800_n14372.t0 TERM_EN5_N.t3 VDD.t362 VDD.t361 pfet_03v3 ad=0.88p pd=4.88u as=0.88p ps=4.88u w=2u l=0.28u
X443 XFRONT.XFE_E.DN.t0 XFRONT.XFE_E.XN.t44 VSS.t26 VSS.t25 nfet_03v3 ad=3.52p pd=16.88u as=2.08p ps=8.52u w=8u l=0.28u
X444 XFRONT.XFE_E.DP.t5 XFRONT.XFE_E.XP.t48 VDD.t475 VDD.t474 pfet_03v3 ad=2.08p pd=8.52u as=2.08p ps=8.52u w=8u l=0.28u
X445 VDD.t318 O_SENSE_CLK.t8 XFRONT.XFE_O.XN.t6 VDD.t317 pfet_03v3 ad=2.08p pd=8.52u as=2.08p ps=8.52u w=8u l=0.28u
X446 XCAP.O_PRST_TAIL.t5 O_CAPTURE_CLKB.t14 VDD.t324 VDD.t323 pfet_03v3 ad=2.08p pd=8.52u as=2.08p ps=8.52u w=8u l=0.28u
X447 VSS.t480 E_SENSE_BOOST.t1 XFRONT.XFE_E.NTAIL.t43 VSS.t479 nfet_03v3 ad=2.6p pd=10.52u as=2.6p ps=10.52u w=10u l=0.28u
X448 VSS.t490 RX_BIAS.t7 a_n5052_n1000.t6 VSS.t487 nfet_03v3 ad=2.6p pd=10.52u as=2.6p ps=10.52u w=10u l=0.28u
X449 XFRONT.XFE_O.NIP.t1 XFRONT.XFE_O.XN.t33 XFRONT.XFE_O.XP.t1 VSS.t21 nfet_03v3 ad=2.08p pd=8.52u as=2.08p ps=8.52u w=8u l=0.28u
X450 XFRONT.XFE_E.NIN.t2 E_SENSE_CLK.t29 VDD.t90 VDD.t89 pfet_03v3 ad=2.08p pd=8.52u as=2.08p ps=8.52u w=8u l=0.28u
X451 VDD.t46 FE_O_N.t18 XCAP.ODD_D_BUF.t0 VDD.t45 pfet_03v3 ad=2.08p pd=8.52u as=3.52p ps=16.88u w=8u l=0.28u
X452 VSS.t138 FE_O_P.t8 XCAP.ODD_DB_BUF.t10 VSS.t137 nfet_03v3 ad=2.08p pd=8.52u as=2.08p ps=8.52u w=8u l=0.28u
X453 XFRONT.XFE_O.NTAIL.t22 O_SENSE_BOOST.t14 VSS.t289 VSS.t288 nfet_03v3 ad=2.6p pd=10.52u as=2.6p ps=10.52u w=10u l=0.28u
X454 XFRONT.XFE_E.DN.t4 XFRONT.XFE_E.XN.t46 VDD.t179 VDD.t178 pfet_03v3 ad=3.52p pd=16.88u as=2.08p ps=8.52u w=8u l=0.28u
X455 XCAP.O_SET_TAIL.t2 XCAP.ODD_D_BUF.t13 XCAP.O_QBI.t8 VSS.t35 nfet_03v3 ad=2.08p pd=8.52u as=2.08p ps=8.52u w=8u l=0.28u
X456 VSS.t512 XFRONT.XFE_E.DP.t11 XFRONT.XFE_E.H.t6 VSS.t511 nfet_03v3 ad=2.08p pd=8.52u as=2.08p ps=8.52u w=8u l=0.28u
X457 VDD.t358 XFRONT.XFE_O.HB.t24 FE_O_N.t2 VDD.t357 pfet_03v3 ad=2.08p pd=8.52u as=3.52p ps=16.88u w=8u l=0.28u
X458 a_n7300_n19900.t0 TERM_EN2_N.t1 a_n6400_n19852.t1 VDD.t152 pfet_03v3 ad=4.4p pd=20.88u as=2.6p ps=10.52u w=10u l=0.28u
X459 a_n6400_n18052.t4 RXN.t3 VSS.t243 ppolyf_u r_width=1u r_length=1u
X460 EVEN_Q.t4 XCAP.E_QBBUF.t9 VDD.t236 VDD.t235 pfet_03v3 ad=2.08p pd=8.52u as=2.08p ps=8.52u w=8u l=0.28u
X461 XCAP.E_PRST_TAIL.t11 E_CAPTURE_CLKB.t8 VDD.t253 VDD.t241 pfet_03v3 ad=3.52p pd=16.88u as=2.08p ps=8.52u w=8u l=0.28u
X462 VSS.t12 XFRONT.XFE_O.XP.t45 XFRONT.XFE_O.DP.t1 VSS.t11 nfet_03v3 ad=2.08p pd=8.52u as=3.52p ps=16.88u w=8u l=0.28u
X463 VSS.t86 FE_O_N.t8 XCAP.ODD_D_BUF.t10 VSS.t39 nfet_03v3 ad=2.08p pd=8.52u as=2.08p ps=8.52u w=8u l=0.28u
X464 XFRONT.XFE_E.NIP.t7 E_SENSE_CLK.t17 VDD.t114 VDD.t113 pfet_03v3 ad=2.08p pd=8.52u as=2.08p ps=8.52u w=8u l=0.28u
X465 XFRONT.XFE_E.NTAIL.t10 RX_RAWP.t19 XFRONT.XFE_E.NIN.t13 VSS.t227 nfet_03v3 ad=2.08p pd=8.52u as=3.52p ps=16.88u w=8u l=0.28u
X466 XFRONT.XFE_O.H.t10 XFRONT.XFE_O.DP.t12 VSS.t379 VSS.t378 nfet_03v3 ad=2.08p pd=8.52u as=2.08p ps=8.52u w=8u l=0.28u
X467 VSS.t59 E_CAPTURE_CLK.t11 XCAP.E_SET_TAIL.t8 VSS.t58 nfet_03v3 ad=2.08p pd=8.52u as=2.08p ps=8.52u w=8u l=0.28u
X468 XCAP.O_QBBUF.t3 XCAP.O_QI.t14 VSS.t40 VSS.t39 nfet_03v3 ad=1.76p pd=8.88u as=1.04p ps=4.52u w=4u l=0.28u
X469 a_n6400_n14452.t2 TERM_EN5_N.t0 a_n7300_n14500.t2 VDD.t364 pfet_03v3 ad=2.6p pd=10.52u as=4.4p ps=20.88u w=10u l=0.28u
X470 RX_RAWP.t3 a_n6572_3500.t6 a_2148_n500.t3 VSS.t82 nfet_03v3 ad=2.2p pd=10.88u as=1.3p ps=5.52u w=5u l=0.28u
X471 VSS.t293 O_SENSE_BOOST.t11 XFRONT.XFE_O.NTAIL.t25 VSS.t292 nfet_03v3 ad=2.6p pd=10.52u as=2.6p ps=10.52u w=10u l=0.28u
X472 VDD.t393 XFRONT.XFE_E.XN.t55 XFRONT.XFE_E.XP.t30 VDD.t392 pfet_03v3 ad=2.08p pd=8.52u as=3.52p ps=16.88u w=8u l=0.28u
X473 XCAP.E_PSET_TAIL.t9 E_CAPTURE_CLKB.t2 VDD.t257 VDD.t251 pfet_03v3 ad=2.08p pd=8.52u as=2.08p ps=8.52u w=8u l=0.28u
X474 XFRONT.XFE_E.H.t3 XFRONT.XFE_E.HB.t24 VDD.t212 VDD.t211 pfet_03v3 ad=2.08p pd=8.52u as=2.08p ps=8.52u w=8u l=0.28u
X475 XFRONT.XFE_O.XN.t23 XFRONT.XFE_O.XP.t38 XFRONT.XFE_O.NIN.t0 VSS.t6 nfet_03v3 ad=2.08p pd=8.52u as=2.08p ps=8.52u w=8u l=0.28u
X476 VDD.t302 O_SENSE_CLK.t14 XFRONT.XFE_O.XN.t0 VDD.t301 pfet_03v3 ad=2.08p pd=8.52u as=3.52p ps=16.88u w=8u l=0.28u
X477 VDD.t342 O_CAPTURE_CLKB.t5 XCAP.O_PSET_TAIL.t6 VDD.t325 pfet_03v3 ad=2.08p pd=8.52u as=2.08p ps=8.52u w=8u l=0.28u
X478 XFRONT.XFE_O.NIN.t19 RX_RAWN.t8 XFRONT.XFE_O.NTAIL.t39 VSS.t406 nfet_03v3 ad=2.08p pd=8.52u as=2.08p ps=8.52u w=8u l=0.28u
X479 ODD_QB.t5 XCAP.O_QBUF.t5 VSS.t159 VSS.t158 nfet_03v3 ad=2.08p pd=8.52u as=2.08p ps=8.52u w=8u l=0.28u
X480 XCAP.O_RST_TAIL.t9 O_CAPTURE_CLK.t2 VSS.t263 VSS.t23 nfet_03v3 ad=2.08p pd=8.52u as=2.08p ps=8.52u w=8u l=0.28u
X481 RXP.t3 a_n7300_n14500.t3 VSS.t115 ppolyf_u r_width=1u r_length=1u
X482 XFRONT.XFE_O.NIP.t10 O_SENSE_CLK.t29 VDD.t284 VDD.t283 pfet_03v3 ad=2.08p pd=8.52u as=2.08p ps=8.52u w=8u l=0.28u
X483 VSS.t207 XFRONT.XFE_O.DP.t9 XFRONT.XFE_O.H.t13 VSS.t206 nfet_03v3 ad=2.08p pd=8.52u as=2.08p ps=8.52u w=8u l=0.28u
X484 XCAP.E_SET_TAIL.t5 E_CAPTURE_CLK.t14 VSS.t54 VSS.t53 nfet_03v3 ad=2.08p pd=8.52u as=2.08p ps=8.52u w=8u l=0.28u
X485 XCAP.O_QI.t8 XCAP.ODD_DB_BUF.t14 XCAP.O_RST_TAIL.t2 VSS.t152 nfet_03v3 ad=2.08p pd=8.52u as=2.08p ps=8.52u w=8u l=0.28u
X486 XFRONT.XFE_E.NIN.t6 XFRONT.XFE_E.XP.t43 XFRONT.XFE_E.XN.t22 VSS.t122 nfet_03v3 ad=2.08p pd=8.52u as=3.52p ps=16.88u w=8u l=0.28u
X487 XFRONT.XFE_E.XP.t19 XFRONT.XFE_E.XN.t42 XFRONT.XFE_E.NIP.t2 VSS.t15 nfet_03v3 ad=2.08p pd=8.52u as=2.08p ps=8.52u w=8u l=0.28u
X488 XCAP.E_PRST_TAIL.t5 E_CAPTURE_CLKB.t14 VDD.t240 VDD.t239 pfet_03v3 ad=2.08p pd=8.52u as=2.08p ps=8.52u w=8u l=0.28u
X489 a_n6572_3500.t1 VTHP.t0 a_n5052_2600.t1 VSS.t117 nfet_03v3 ad=0.88p pd=4.88u as=0.52p ps=2.52u w=2u l=0.28u
X490 XCAP.E_QI.t1 XCAP.EVEN_DB_BUF.t14 XCAP.E_RST_TAIL.t11 VSS.t56 nfet_03v3 ad=2.08p pd=8.52u as=2.08p ps=8.52u w=8u l=0.28u
X491 VSS.t458 E_SENSE_BOOST.t9 XFRONT.XFE_E.NTAIL.t35 VSS.t457 nfet_03v3 ad=2.6p pd=10.52u as=2.6p ps=10.52u w=10u l=0.28u
X492 XFRONT.XFE_O.XN.t3 O_SENSE_CLK.t11 VDD.t296 VDD.t295 pfet_03v3 ad=2.08p pd=8.52u as=2.08p ps=8.52u w=8u l=0.28u
X493 XFRONT.XFE_O.NTAIL.t41 RX_RAWN.t5 XFRONT.XFE_O.NIN.t22 VSS.t409 nfet_03v3 ad=2.08p pd=8.52u as=2.08p ps=8.52u w=8u l=0.28u
X494 XCAP.E_SET_TAIL.t1 XCAP.EVEN_D_BUF.t13 XCAP.E_QBI.t1 VSS.t17 nfet_03v3 ad=2.08p pd=8.52u as=2.08p ps=8.52u w=8u l=0.28u
X495 a_2148_n500.t5 RX_BIAS.t3 VSS.t495 VSS.t491 nfet_03v3 ad=2.6p pd=10.52u as=2.6p ps=10.52u w=10u l=0.28u
X496 VDD.t15 XCAP.E_QBUF.t10 EVEN_QB.t1 VDD.t14 pfet_03v3 ad=2.08p pd=8.52u as=3.52p ps=16.88u w=8u l=0.28u
X497 VSS.t427 XFRONT.XFE_E.H.t18 FE_E_N.t1 VSS.t426 nfet_03v3 ad=2.08p pd=8.52u as=2.08p ps=8.52u w=8u l=0.28u
X498 VDD.t201 XCAP.O_QBI.t17 XCAP.O_QI.t10 VDD.t13 pfet_03v3 ad=2.08p pd=8.52u as=3.52p ps=16.88u w=8u l=0.28u
X499 VDD.t360 XFRONT.XFE_O.XP.t55 XFRONT.XFE_O.XN.t30 VDD.t359 pfet_03v3 ad=2.08p pd=8.52u as=3.52p ps=16.88u w=8u l=0.28u
X500 a_n10800_n17972.t0 TERM_EN3_N.t3 VDD.t171 VDD.t170 pfet_03v3 ad=0.88p pd=4.88u as=0.88p ps=4.88u w=2u l=0.28u
X501 VSS.t281 O_SENSE_BOOST.t17 XFRONT.XFE_O.NTAIL.t19 VSS.t280 nfet_03v3 ad=2.6p pd=10.52u as=2.6p ps=10.52u w=10u l=0.28u
X502 XFRONT.XFE_O.NTAIL.t7 RX_RAWP.t7 XFRONT.XFE_O.NIP.t17 VSS.t239 nfet_03v3 ad=2.08p pd=8.52u as=2.08p ps=8.52u w=8u l=0.28u
X503 VDD.t471 a_n1900_5958.t1 VSS.t508 ppolyf_u r_width=1u r_length=1.4u
X504 XFRONT.XFE_E.XP.t11 E_SENSE_CLK.t11 VDD.t102 VDD.t101 pfet_03v3 ad=2.08p pd=8.52u as=2.08p ps=8.52u w=8u l=0.28u
X505 a_n7157_n21700.t1 TERM_EN1_N.t1 a_n6400_n21652.t1 VDD.t176 pfet_03v3 ad=4.4p pd=20.88u as=2.6p ps=10.52u w=10u l=0.28u
X506 VDD.t228 XCAP.E_QBI.t17 XCAP.E_QI.t8 VDD.t3 pfet_03v3 ad=2.08p pd=8.52u as=3.52p ps=16.88u w=8u l=0.28u
X507 VDD.t214 XFRONT.XFE_E.XP.t55 XFRONT.XFE_E.HB.t11 VDD.t213 pfet_03v3 ad=2.08p pd=8.52u as=3.52p ps=16.88u w=8u l=0.28u
X508 VDD.t387 XFRONT.XFE_E.XN.t53 XFRONT.XFE_E.H.t15 VDD.t386 pfet_03v3 ad=2.08p pd=8.52u as=3.52p ps=16.88u w=8u l=0.28u
X509 a_n7300_n12700.t3 a_n10800_n12572.t3 a_n6400_n12652.t3 VSS.t216 nfet_03v3 ad=4.4p pd=20.88u as=2.6p ps=10.52u w=10u l=0.28u
X510 VSS.t104 E_SENSE_CLK.t1 XFRONT.XFE_E.NTAIL.t3 VSS.t103 nfet_03v3 ad=2.6p pd=10.52u as=2.6p ps=10.52u w=10u l=0.28u
X511 XFRONT.XFE_E.NTAIL.t32 E_SENSE_BOOST.t12 VSS.t460 VSS.t459 nfet_03v3 ad=2.6p pd=10.52u as=2.6p ps=10.52u w=10u l=0.28u
X512 VDD.t262 O_SENSE_CLK.t38 XFRONT.XFE_O.XP.t18 VDD.t261 pfet_03v3 ad=2.08p pd=8.52u as=2.08p ps=8.52u w=8u l=0.28u
X513 VSS.t38 XCAP.O_QI.t13 XCAP.O_QBI.t3 VSS.t37 nfet_03v3 ad=2.08p pd=8.52u as=3.52p ps=16.88u w=8u l=0.28u
X514 EVEN_QB.t3 XCAP.E_QBUF.t7 VDD.t224 VDD.t223 pfet_03v3 ad=3.52p pd=16.88u as=2.08p ps=8.52u w=8u l=0.28u
X515 VDD.t432 XCAP.O_QBI.t19 XCAP.O_QBUF.t3 VDD.t431 pfet_03v3 ad=2.08p pd=8.52u as=3.52p ps=16.88u w=8u l=0.28u
X516 VSS.t307 O_SENSE_BOOST.t3 XFRONT.XFE_O.NTAIL.t33 VSS.t306 nfet_03v3 ad=2.6p pd=10.52u as=2.6p ps=10.52u w=10u l=0.28u
X517 XFRONT.XFE_E.NIN.t8 XFRONT.XFE_E.XP.t37 XFRONT.XFE_E.XN.t24 VSS.t172 nfet_03v3 ad=2.08p pd=8.52u as=2.08p ps=8.52u w=8u l=0.28u
X518 VSS.t247 O_CAPTURE_CLK.t15 XCAP.O_SET_TAIL.t4 VSS.t246 nfet_03v3 ad=2.08p pd=8.52u as=3.52p ps=16.88u w=8u l=0.28u
X519 VDD.t373 XFRONT.XFE_O.H.t25 XFRONT.XFE_O.HB.t10 VDD.t372 pfet_03v3 ad=2.08p pd=8.52u as=3.52p ps=16.88u w=8u l=0.28u
X520 XFRONT.XFE_O.NIP.t20 RX_RAWP.t4 XFRONT.XFE_O.NTAIL.t5 VSS.t242 nfet_03v3 ad=3.52p pd=16.88u as=2.08p ps=8.52u w=8u l=0.28u
X521 VDD.t207 a_n6716_3500.t0 VSS.t181 ppolyf_u r_width=1u r_length=1.4u
X522 XFRONT.XFE_E.XP.t25 XFRONT.XFE_E.XN.t36 XFRONT.XFE_E.NIP.t15 VSS.t149 nfet_03v3 ad=2.08p pd=8.52u as=2.08p ps=8.52u w=8u l=0.28u
X523 VDD.t108 E_SENSE_CLK.t14 XFRONT.XFE_E.XP.t8 VDD.t107 pfet_03v3 ad=2.08p pd=8.52u as=3.52p ps=16.88u w=8u l=0.28u
X524 VDD.t238 E_CAPTURE_CLKB.t5 XCAP.E_PSET_TAIL.t6 VDD.t237 pfet_03v3 ad=2.08p pd=8.52u as=2.08p ps=8.52u w=8u l=0.28u
X525 a_n5052_2600.t0 VTHP.t1 a_n6572_3500.t0 VSS.t117 nfet_03v3 ad=0.52p pd=2.52u as=0.88p ps=4.88u w=2u l=0.28u
X526 a_n6400_n18052.t1 TERM_EN3_N.t0 a_n7300_n18100.t1 VDD.t173 pfet_03v3 ad=2.6p pd=10.52u as=4.4p ps=20.88u w=10u l=0.28u
X527 XFRONT.XFE_O.DP.t0 XFRONT.XFE_O.XP.t44 VSS.t10 VSS.t9 nfet_03v3 ad=3.52p pd=16.88u as=2.08p ps=8.52u w=8u l=0.28u
X528 XCAP.O_PRST_TAIL.t7 O_CAPTURE_CLKB.t12 VDD.t330 VDD.t329 pfet_03v3 ad=2.08p pd=8.52u as=2.08p ps=8.52u w=8u l=0.28u
X529 XCAP.E_RST_TAIL.t7 E_CAPTURE_CLK.t2 VSS.t69 VSS.t16 nfet_03v3 ad=2.08p pd=8.52u as=2.08p ps=8.52u w=8u l=0.28u
X530 VSS.t476 E_SENSE_BOOST.t3 XFRONT.XFE_E.NTAIL.t41 VSS.t475 nfet_03v3 ad=2.6p pd=10.52u as=2.6p ps=10.52u w=10u l=0.28u
X531 VDD.t54 FE_O_N.t16 XCAP.ODD_D_BUF.t2 VDD.t53 pfet_03v3 ad=2.08p pd=8.52u as=2.08p ps=8.52u w=8u l=0.28u
X532 a_5300_5958.t1 RX_BW_EN_N.t0 RX_RAWN.t2 VDD.t350 pfet_03v3 ad=2.2p pd=10.88u as=2.2p ps=10.88u w=5u l=0.28u
X533 VDD.t183 XCAP.O_QBBUF.t8 ODD_Q.t4 VDD.t182 pfet_03v3 ad=2.08p pd=8.52u as=2.08p ps=8.52u w=8u l=0.28u
X534 VSS.t244 O_CAPTURE_CLK.t5 XCAP.O_RST_TAIL.t6 VSS.t83 nfet_03v3 ad=2.08p pd=8.52u as=2.08p ps=8.52u w=8u l=0.28u
X535 XFRONT.XFE_O.NIN.t13 O_SENSE_CLK.t17 VDD.t306 VDD.t305 pfet_03v3 ad=2.08p pd=8.52u as=2.08p ps=8.52u w=8u l=0.28u
X536 XFRONT.XFE_O.XP.t21 O_SENSE_CLK.t35 VDD.t278 VDD.t277 pfet_03v3 ad=2.08p pd=8.52u as=2.08p ps=8.52u w=8u l=0.28u
X537 XCAP.ODD_DB_BUF.t5 FE_O_P.t13 VDD.t157 VDD.t156 pfet_03v3 ad=2.08p pd=8.52u as=2.08p ps=8.52u w=8u l=0.28u
X538 VDD.t149 a_n3600_5641.t2 VSS.t131 ppolyf_u r_width=2u r_length=4.57u
X539 RXP.t6 a_n7300_n18100.t4 VSS.t115 ppolyf_u r_width=1u r_length=1u
X540 XFRONT.XFE_O.HB.t5 XFRONT.XFE_O.DN.t8 VSS.t358 VSS.t357 nfet_03v3 ad=2.08p pd=8.52u as=2.08p ps=8.52u w=8u l=0.28u
X541 XFRONT.XFE_E.XP.t5 E_SENSE_CLK.t21 XFRONT.XFE_E.XN.t4 VDD.t98 pfet_03v3 ad=2.08p pd=8.52u as=2.08p ps=8.52u w=8u l=0.28u
X542 XFRONT.XFE_O.NTAIL.t36 O_SENSE_BOOST.t0 VSS.t301 VSS.t300 nfet_03v3 ad=4.4p pd=20.88u as=2.6p ps=10.52u w=10u l=0.28u
X543 XFRONT.XFE_E.XN.t30 XFRONT.XFE_E.XP.t40 XFRONT.XFE_E.NIN.t22 VSS.t422 nfet_03v3 ad=2.08p pd=8.52u as=2.08p ps=8.52u w=8u l=0.28u
X544 XFRONT.XFE_O.NIP.t21 XFRONT.XFE_O.XN.t41 XFRONT.XFE_O.XP.t29 VSS.t501 nfet_03v3 ad=2.08p pd=8.52u as=2.08p ps=8.52u w=8u l=0.28u
X545 XFRONT.XFE_O.HB.t11 XFRONT.XFE_O.H.t22 VDD.t377 VDD.t376 pfet_03v3 ad=3.52p pd=16.88u as=2.08p ps=8.52u w=8u l=0.28u
X546 XFRONT.XFE_O.XP.t15 O_SENSE_CLK.t19 XFRONT.XFE_O.XN.t17 VDD.t294 pfet_03v3 ad=3.52p pd=16.88u as=2.08p ps=8.52u w=8u l=0.28u
X547 VDD.t187 XCAP.E_QI.t19 XCAP.E_QBBUF.t0 VDD.t129 pfet_03v3 ad=2.08p pd=8.52u as=3.52p ps=16.88u w=8u l=0.28u
X548 VSS.t19 XCAP.E_QBUF.t6 EVEN_QB.t0 VSS.t18 nfet_03v3 ad=2.08p pd=8.52u as=3.52p ps=16.88u w=8u l=0.28u
X549 XFRONT.XFE_E.NIP.t12 XFRONT.XFE_E.XN.t39 XFRONT.XFE_E.XP.t22 VSS.t120 nfet_03v3 ad=2.08p pd=8.52u as=2.08p ps=8.52u w=8u l=0.28u
X550 VDD.t338 O_CAPTURE_CLKB.t9 XCAP.O_PRST_TAIL.t10 VDD.t337 pfet_03v3 ad=2.08p pd=8.52u as=2.08p ps=8.52u w=8u l=0.28u
X551 XFRONT.XFE_E.NTAIL.t38 E_SENSE_BOOST.t6 VSS.t456 VSS.t455 nfet_03v3 ad=2.6p pd=10.52u as=2.6p ps=10.52u w=10u l=0.28u
X552 VDD.t11 XFRONT.XFE_O.XN.t49 XFRONT.XFE_O.DN.t2 VDD.t10 pfet_03v3 ad=2.08p pd=8.52u as=3.52p ps=16.88u w=8u l=0.28u
X553 XCAP.ODD_D_BUF.t5 FE_O_N.t13 VDD.t56 VDD.t55 pfet_03v3 ad=2.08p pd=8.52u as=2.08p ps=8.52u w=8u l=0.28u
X554 VSS.t297 O_SENSE_BOOST.t9 XFRONT.XFE_O.NTAIL.t27 VSS.t296 nfet_03v3 ad=2.6p pd=10.52u as=2.6p ps=10.52u w=10u l=0.28u
X555 VDD.t440 XFRONT.XFE_E.H.t23 FE_E_N.t2 VDD.t439 pfet_03v3 ad=2.08p pd=8.52u as=2.08p ps=8.52u w=8u l=0.28u
X556 XFRONT.XFE_O.NIP.t14 RX_RAWP.t10 XFRONT.XFE_O.NTAIL.t11 VSS.t236 nfet_03v3 ad=2.08p pd=8.52u as=2.08p ps=8.52u w=8u l=0.28u
X557 VSS.t331 XFRONT.XFE_O.HB.t18 FE_O_N.t4 VSS.t330 nfet_03v3 ad=2.08p pd=8.52u as=2.08p ps=8.52u w=8u l=0.28u
X558 a_n3600_5641.t1 RXN.t8 a_n5052_n1000.t0 VSS.t82 nfet_03v3 ad=4.4p pd=20.88u as=2.6p ps=10.52u w=10u l=0.28u
X559 VDD.t126 E_SENSE_CLK.t8 XFRONT.XFE_E.XP.t14 VDD.t125 pfet_03v3 ad=2.08p pd=8.52u as=2.08p ps=8.52u w=8u l=0.28u
X560 VSS.t197 XFRONT.XFE_E.DN.t9 XFRONT.XFE_E.HB.t7 VSS.t196 nfet_03v3 ad=2.08p pd=8.52u as=2.08p ps=8.52u w=8u l=0.28u
X561 VDD.t344 O_CAPTURE_CLKB.t3 XCAP.O_PSET_TAIL.t8 VDD.t331 pfet_03v3 ad=2.08p pd=8.52u as=2.08p ps=8.52u w=8u l=0.28u
X562 VDD.t397 XFRONT.XFE_O.XN.t51 XFRONT.XFE_O.XP.t28 VDD.t396 pfet_03v3 ad=2.08p pd=8.52u as=3.52p ps=16.88u w=8u l=0.28u
X563 XFRONT.XFE_E.XN.t17 E_SENSE_CLK.t24 XFRONT.XFE_E.XP.t2 VDD.t95 pfet_03v3 ad=2.08p pd=8.52u as=2.08p ps=8.52u w=8u l=0.28u
X564 XCAP.E_PRST_TAIL.t1 XCAP.EVEN_D_BUF.t19 XCAP.E_QBI.t3 VDD.t16 pfet_03v3 ad=2.08p pd=8.52u as=3.52p ps=16.88u w=8u l=0.28u
X565 VSS.t314 XCAP.E_QI.t13 XCAP.E_QBI.t6 VSS.t29 nfet_03v3 ad=2.08p pd=8.52u as=3.52p ps=16.88u w=8u l=0.28u
X566 XFRONT.XFE_E.HB.t2 XFRONT.XFE_E.XP.t52 VDD.t41 VDD.t40 pfet_03v3 ad=3.52p pd=16.88u as=2.08p ps=8.52u w=8u l=0.28u
X567 XFRONT.XFE_E.H.t12 XFRONT.XFE_E.XN.t50 VDD.t381 VDD.t380 pfet_03v3 ad=3.52p pd=16.88u as=2.08p ps=8.52u w=8u l=0.28u
X568 VSS.t192 XFRONT.XFE_O.DP.t7 XFRONT.XFE_O.H.t15 VSS.t191 nfet_03v3 ad=2.08p pd=8.52u as=2.08p ps=8.52u w=8u l=0.28u
X569 XFRONT.XFE_O.DN.t5 XFRONT.XFE_O.XN.t46 VDD.t37 VDD.t36 pfet_03v3 ad=3.52p pd=16.88u as=2.08p ps=8.52u w=8u l=0.28u
X570 VDD.t31 RX_RAWP.t0 VSS.t77 ppolyf_u r_width=2u r_length=3.43u
X571 a_n7300_n16300.t1 a_n10800_n16172.t3 a_n6400_n16252.t2 VSS.t210 nfet_03v3 ad=4.4p pd=20.88u as=2.6p ps=10.52u w=10u l=0.28u
X572 XFRONT.XFE_O.NTAIL.t30 O_SENSE_BOOST.t6 VSS.t309 VSS.t78 nfet_03v3 ad=2.6p pd=10.52u as=2.6p ps=10.52u w=10u l=0.28u
X573 XFRONT.XFE_E.XN.t27 XFRONT.XFE_E.XP.t34 XFRONT.XFE_E.NIN.t11 VSS.t194 nfet_03v3 ad=2.08p pd=8.52u as=2.08p ps=8.52u w=8u l=0.28u
X574 XFRONT.XFE_O.XP.t12 O_SENSE_CLK.t25 XFRONT.XFE_O.XN.t11 VDD.t288 pfet_03v3 ad=2.08p pd=8.52u as=2.08p ps=8.52u w=8u l=0.28u
X575 XCAP.EVEN_DB_BUF.t5 FE_E_P.t13 VDD.t421 VDD.t420 pfet_03v3 ad=2.08p pd=8.52u as=2.08p ps=8.52u w=8u l=0.28u
X576 a_n10800_n14372.t1 TERM_EN5_N.t2 VSS.t323 VSS.t43 nfet_03v3 ad=0.44p pd=2.88u as=0.44p ps=2.88u w=1u l=0.28u
X577 XCAP.E_PRST_TAIL.t7 E_CAPTURE_CLKB.t12 VDD.t250 VDD.t184 pfet_03v3 ad=2.08p pd=8.52u as=2.08p ps=8.52u w=8u l=0.28u
X578 XCAP.E_PSET_TAIL.t0 XCAP.EVEN_DB_BUF.t17 XCAP.E_QI.t6 VDD.t2 pfet_03v3 ad=2.08p pd=8.52u as=2.08p ps=8.52u w=8u l=0.28u
X579 XFRONT.XFE_O.NIN.t7 XFRONT.XFE_O.XP.t33 XFRONT.XFE_O.XN.t28 VSS.t75 nfet_03v3 ad=2.08p pd=8.52u as=2.08p ps=8.52u w=8u l=0.28u
X580 VSS.t95 XCAP.O_QBBUF.t4 ODD_Q.t3 VSS.t94 nfet_03v3 ad=3.52p pd=16.88u as=2.08p ps=8.52u w=8u l=0.28u
X581 XFRONT.XFE_E.HB.t4 XFRONT.XFE_E.DN.t12 VSS.t213 VSS.t212 nfet_03v3 ad=2.08p pd=8.52u as=2.08p ps=8.52u w=8u l=0.28u
X582 VDD.t473 XFRONT.XFE_E.XP.t47 XFRONT.XFE_E.DP.t4 VDD.t472 pfet_03v3 ad=2.08p pd=8.52u as=2.08p ps=8.52u w=8u l=0.28u
X583 XFRONT.XFE_O.XN.t5 O_SENSE_CLK.t9 VDD.t320 VDD.t319 pfet_03v3 ad=2.08p pd=8.52u as=2.08p ps=8.52u w=8u l=0.28u
X584 VSS.t67 E_CAPTURE_CLK.t5 XCAP.E_RST_TAIL.t4 VSS.t30 nfet_03v3 ad=2.08p pd=8.52u as=2.08p ps=8.52u w=8u l=0.28u
X585 XCAP.O_PSET_TAIL.t11 O_CAPTURE_CLKB.t0 VDD.t339 VDD.t333 pfet_03v3 ad=3.52p pd=16.88u as=2.08p ps=8.52u w=8u l=0.28u
X586 a_2148_n500.t7 RX_BIAS.t1 VSS.t497 VSS.t491 nfet_03v3 ad=2.6p pd=10.52u as=2.6p ps=10.52u w=10u l=0.28u
X587 XFRONT.XFE_E.NTAIL.t44 E_SENSE_BOOST.t0 VSS.t472 VSS.t471 nfet_03v3 ad=4.4p pd=20.88u as=2.6p ps=10.52u w=10u l=0.28u
X588 a_n5052_n1000.t7 RX_BIAS.t6 VSS.t492 VSS.t491 nfet_03v3 ad=2.6p pd=10.52u as=2.6p ps=10.52u w=10u l=0.28u
X589 a_n10800_n23372.t0 TERM_EN0_N.t3 VDD.t407 VDD.t406 pfet_03v3 ad=0.88p pd=4.88u as=0.88p ps=4.88u w=2u l=0.28u
X590 XFRONT.XFE_E.NTAIL.t2 E_SENSE_CLK.t2 VSS.t102 VSS.t101 nfet_03v3 ad=2.6p pd=10.52u as=2.6p ps=10.52u w=10u l=0.28u
X591 VSS.t431 XFRONT.XFE_E.H.t20 FE_E_N.t5 VSS.t430 nfet_03v3 ad=2.08p pd=8.52u as=3.52p ps=16.88u w=8u l=0.28u
X592 XCAP.O_QBI.t9 XCAP.ODD_D_BUF.t14 XCAP.O_SET_TAIL.t3 VSS.t37 nfet_03v3 ad=2.08p pd=8.52u as=2.08p ps=8.52u w=8u l=0.28u
X593 XFRONT.XFE_O.H.t5 XFRONT.XFE_O.HB.t25 VDD.t466 VDD.t465 pfet_03v3 ad=3.52p pd=16.88u as=2.08p ps=8.52u w=8u l=0.28u
X594 VDD.t165 FE_O_P.t16 XCAP.ODD_DB_BUF.t2 VDD.t164 pfet_03v3 ad=2.08p pd=8.52u as=2.08p ps=8.52u w=8u l=0.28u
X595 VSS.t373 XFRONT.XFE_O.DN.t11 XFRONT.XFE_O.HB.t2 VSS.t372 nfet_03v3 ad=2.08p pd=8.52u as=2.08p ps=8.52u w=8u l=0.28u
X596 VDD.t22 XCAP.E_QBBUF.t8 EVEN_Q.t1 VDD.t21 pfet_03v3 ad=2.08p pd=8.52u as=2.08p ps=8.52u w=8u l=0.28u
X597 XFRONT.XFE_E.XN.t16 E_SENSE_CLK.t31 VDD.t66 VDD.t65 pfet_03v3 ad=3.52p pd=16.88u as=2.08p ps=8.52u w=8u l=0.28u
X598 XFRONT.XFE_O.XN.t14 O_SENSE_CLK.t22 XFRONT.XFE_O.XP.t9 VDD.t291 pfet_03v3 ad=2.08p pd=8.52u as=2.08p ps=8.52u w=8u l=0.28u
X599 VDD.t415 FE_E_P.t16 XCAP.EVEN_DB_BUF.t2 VDD.t414 pfet_03v3 ad=2.08p pd=8.52u as=2.08p ps=8.52u w=8u l=0.28u
X600 VDD.t244 E_CAPTURE_CLKB.t9 XCAP.E_PRST_TAIL.t10 VDD.t243 pfet_03v3 ad=2.08p pd=8.52u as=2.08p ps=8.52u w=8u l=0.28u
X601 VSS.t108 FE_E_N.t8 XCAP.EVEN_D_BUF.t10 VSS.t107 nfet_03v3 ad=2.08p pd=8.52u as=2.08p ps=8.52u w=8u l=0.28u
X602 XCAP.ODD_D_BUF.t9 FE_O_N.t9 VSS.t85 VSS.t84 nfet_03v3 ad=2.08p pd=8.52u as=2.08p ps=8.52u w=8u l=0.28u
X603 VDD.t116 E_SENSE_CLK.t16 XFRONT.XFE_E.NIP.t8 VDD.t115 pfet_03v3 ad=2.08p pd=8.52u as=2.08p ps=8.52u w=8u l=0.28u
X604 VDD.t298 O_SENSE_CLK.t6 XFRONT.XFE_O.XN.t8 VDD.t297 pfet_03v3 ad=2.08p pd=8.52u as=2.08p ps=8.52u w=8u l=0.28u
X605 a_n7300_n19900.t3 a_n10800_n19772.t3 a_n6400_n19852.t4 VSS.t366 nfet_03v3 ad=4.4p pd=20.88u as=2.6p ps=10.52u w=10u l=0.28u
X606 XFRONT.XFE_E.NTAIL.t19 RX_RAWN.t13 XFRONT.XFE_E.NIP.t22 VSS.t401 nfet_03v3 ad=2.08p pd=8.52u as=2.08p ps=8.52u w=8u l=0.28u
X607 FE_E_P.t3 XFRONT.XFE_E.HB.t20 VSS.t179 VSS.t178 nfet_03v3 ad=2.08p pd=8.52u as=2.08p ps=8.52u w=8u l=0.28u
X608 XCAP.E_QBBUF.t3 XCAP.E_QI.t14 VSS.t315 VSS.t107 nfet_03v3 ad=1.76p pd=8.88u as=1.04p ps=4.52u w=4u l=0.28u
X609 VSS.t489 RX_BIAS.t9 a_n5052_n1000.t4 VSS.t487 nfet_03v3 ad=2.6p pd=10.52u as=4.4p ps=20.88u w=10u l=0.28u
X610 VSS.t434 XCAP.O_QI.t15 XCAP.O_QBBUF.t2 VSS.t84 nfet_03v3 ad=1.04p pd=4.52u as=1.76p ps=8.88u w=4u l=0.28u
X611 a_n6400_n23452.t0 RXN.t2 VSS.t141 ppolyf_u r_width=1u r_length=2.43u
X612 XFRONT.XFE_E.XP.t31 XFRONT.XFE_E.XN.t54 VDD.t391 VDD.t390 pfet_03v3 ad=3.52p pd=16.88u as=2.08p ps=8.52u w=8u l=0.28u
X613 a_n6400_n23452.t4 TERM_EN0_N.t0 a_n7157_n23500.t4 VDD.t409 pfet_03v3 ad=2.6p pd=10.52u as=4.4p ps=20.88u w=10u l=0.28u
X614 XFRONT.XFE_O.NTAIL.t24 O_SENSE_BOOST.t12 VSS.t283 VSS.t282 nfet_03v3 ad=2.6p pd=10.52u as=2.6p ps=10.52u w=10u l=0.28u
X615 VSS.t317 XFRONT.XFE_E.DP.t13 XFRONT.XFE_E.H.t4 VSS.t316 nfet_03v3 ad=2.08p pd=8.52u as=3.52p ps=16.88u w=8u l=0.28u
X616 VDD.t354 XFRONT.XFE_O.HB.t22 FE_O_N.t0 VDD.t353 pfet_03v3 ad=3.52p pd=16.88u as=2.08p ps=8.52u w=8u l=0.28u
X617 VDD.t210 XFRONT.XFE_E.HB.t23 XFRONT.XFE_E.H.t2 VDD.t209 pfet_03v3 ad=2.08p pd=8.52u as=2.08p ps=8.52u w=8u l=0.28u
X618 VDD.t255 E_CAPTURE_CLKB.t3 XCAP.E_PSET_TAIL.t8 VDD.t188 pfet_03v3 ad=2.08p pd=8.52u as=2.08p ps=8.52u w=8u l=0.28u
X619 VDD.t405 XFRONT.XFE_O.XP.t49 XFRONT.XFE_O.DP.t5 VDD.t404 pfet_03v3 ad=2.08p pd=8.52u as=3.52p ps=16.88u w=8u l=0.28u
X620 XCAP.EVEN_D_BUF.t3 FE_E_N.t15 VDD.t130 VDD.t129 pfet_03v3 ad=2.08p pd=8.52u as=2.08p ps=8.52u w=8u l=0.28u
X621 XCAP.O_PSET_TAIL.t5 O_CAPTURE_CLKB.t6 VDD.t341 VDD.t323 pfet_03v3 ad=2.08p pd=8.52u as=2.08p ps=8.52u w=8u l=0.28u
X622 a_n6400_n14452.t4 a_n10800_n14372.t2 a_n7300_n14500.t4 VSS.t360 nfet_03v3 ad=2.6p pd=10.52u as=4.4p ps=20.88u w=10u l=0.28u
X623 XFRONT.XFE_O.NTAIL.t1 O_SENSE_CLK.t3 VSS.t218 VSS.t217 nfet_03v3 ad=2.6p pd=10.52u as=2.6p ps=10.52u w=10u l=0.28u
X624 VSS.t262 O_CAPTURE_CLK.t3 XCAP.O_RST_TAIL.t8 VSS.t35 nfet_03v3 ad=2.08p pd=8.52u as=2.08p ps=8.52u w=8u l=0.28u
X625 XCAP.O_PRST_TAIL.t1 XCAP.ODD_D_BUF.t19 XCAP.O_QBI.t7 VDD.t23 pfet_03v3 ad=2.08p pd=8.52u as=3.52p ps=16.88u w=8u l=0.28u
X626 XCAP.O_QBBUF.t1 XCAP.O_QI.t18 VDD.t449 VDD.t59 pfet_03v3 ad=3.52p pd=16.88u as=2.08p ps=8.52u w=8u l=0.28u
X627 VSS.t449 E_SENSE_BOOST.t17 XFRONT.XFE_E.NTAIL.t27 VSS.t27 nfet_03v3 ad=2.6p pd=10.52u as=2.6p ps=10.52u w=10u l=0.28u
X628 XFRONT.XFE_O.H.t12 XFRONT.XFE_O.DP.t10 VSS.t166 VSS.t165 nfet_03v3 ad=2.08p pd=8.52u as=2.08p ps=8.52u w=8u l=0.28u
X629 XFRONT.XFE_E.NIP.t19 RX_RAWN.t16 XFRONT.XFE_E.NTAIL.t14 VSS.t398 nfet_03v3 ad=2.08p pd=8.52u as=2.08p ps=8.52u w=8u l=0.28u
X630 VSS.t55 E_CAPTURE_CLK.t13 XCAP.E_SET_TAIL.t6 VSS.t33 nfet_03v3 ad=2.08p pd=8.52u as=2.08p ps=8.52u w=8u l=0.28u
X631 XFRONT.XFE_E.XN.t21 XFRONT.XFE_E.XP.t42 XFRONT.XFE_E.NIN.t5 VSS.t121 nfet_03v3 ad=2.08p pd=8.52u as=2.08p ps=8.52u w=8u l=0.28u
X632 VDD.t426 a_484_3500.t1 VSS.t394 ppolyf_u r_width=1u r_length=1.4u
X633 XCAP.E_PSET_TAIL.t11 E_CAPTURE_CLKB.t0 VDD.t242 VDD.t241 pfet_03v3 ad=3.52p pd=16.88u as=2.08p ps=8.52u w=8u l=0.28u
X634 XCAP.O_QBI.t2 XCAP.O_QI.t16 VDD.t451 VDD.t331 pfet_03v3 ad=3.52p pd=16.88u as=2.08p ps=8.52u w=8u l=0.28u
X635 XCAP.E_RST_TAIL.t10 XCAP.EVEN_DB_BUF.t13 XCAP.E_QI.t2 VSS.t58 nfet_03v3 ad=2.08p pd=8.52u as=2.08p ps=8.52u w=8u l=0.28u
X636 VDD.t304 O_SENSE_CLK.t12 XFRONT.XFE_O.XN.t2 VDD.t303 pfet_03v3 ad=2.08p pd=8.52u as=2.08p ps=8.52u w=8u l=0.28u
R0 TERM_EN0_N.n0 TERM_EN0_N.t1 139.688
R1 TERM_EN0_N.n0 TERM_EN0_N.t0 139.688
R2 TERM_EN0_N.n2 TERM_EN0_N.t3 62.9541
R3 TERM_EN0_N.n1 TERM_EN0_N.t2 49.9184
R4 TERM_EN0_N.n1 TERM_EN0_N.n0 22.445
R5 TERM_EN0_N.n2 TERM_EN0_N.n1 0.8735
R6 TERM_EN0_N TERM_EN0_N.n2 0.539857
R7 TERM_EN1_N.n0 TERM_EN1_N.t1 139.688
R8 TERM_EN1_N.n0 TERM_EN1_N.t0 139.688
R9 TERM_EN1_N.n2 TERM_EN1_N.t3 62.9541
R10 TERM_EN1_N.n1 TERM_EN1_N.t2 49.9184
R11 TERM_EN1_N.n1 TERM_EN1_N.n0 22.445
R12 TERM_EN1_N.n2 TERM_EN1_N.n1 0.8735
R13 TERM_EN1_N TERM_EN1_N.n2 0.539857
R14 TERM_EN2_N.n0 TERM_EN2_N.t1 139.688
R15 TERM_EN2_N.n0 TERM_EN2_N.t0 139.688
R16 TERM_EN2_N.n2 TERM_EN2_N.t3 62.9541
R17 TERM_EN2_N.n1 TERM_EN2_N.t2 49.9184
R18 TERM_EN2_N.n1 TERM_EN2_N.n0 22.445
R19 TERM_EN2_N.n2 TERM_EN2_N.n1 0.8735
R20 TERM_EN2_N TERM_EN2_N.n2 0.539857
R21 TERM_EN3_N.n0 TERM_EN3_N.t1 139.688
R22 TERM_EN3_N.n0 TERM_EN3_N.t0 139.688
R23 TERM_EN3_N.n2 TERM_EN3_N.t3 62.9541
R24 TERM_EN3_N.n1 TERM_EN3_N.t2 49.9184
R25 TERM_EN3_N.n1 TERM_EN3_N.n0 22.445
R26 TERM_EN3_N.n2 TERM_EN3_N.n1 0.8735
R27 TERM_EN3_N TERM_EN3_N.n2 0.539857
R28 TERM_EN4_N.n0 TERM_EN4_N.t1 139.688
R29 TERM_EN4_N.n0 TERM_EN4_N.t0 139.688
R30 TERM_EN4_N.n2 TERM_EN4_N.t3 62.9541
R31 TERM_EN4_N.n1 TERM_EN4_N.t2 49.9184
R32 TERM_EN4_N.n1 TERM_EN4_N.n0 22.445
R33 TERM_EN4_N.n2 TERM_EN4_N.n1 0.8735
R34 TERM_EN4_N TERM_EN4_N.n2 0.539857
R35 TERM_EN5_N.n0 TERM_EN5_N.t1 139.688
R36 TERM_EN5_N.n0 TERM_EN5_N.t0 139.688
R37 TERM_EN5_N.n2 TERM_EN5_N.t3 62.9541
R38 TERM_EN5_N.n1 TERM_EN5_N.t2 49.9184
R39 TERM_EN5_N.n1 TERM_EN5_N.n0 22.445
R40 TERM_EN5_N.n2 TERM_EN5_N.n1 0.8735
R41 TERM_EN5_N TERM_EN5_N.n2 0.539857
R42 TERM_EN6_N.n0 TERM_EN6_N.t1 139.688
R43 TERM_EN6_N.n0 TERM_EN6_N.t0 139.688
R44 TERM_EN6_N.n2 TERM_EN6_N.t3 62.9541
R45 TERM_EN6_N.n1 TERM_EN6_N.t2 49.9184
R46 TERM_EN6_N.n1 TERM_EN6_N.n0 22.445
R47 TERM_EN6_N.n2 TERM_EN6_N.n1 0.8735
R48 TERM_EN6_N TERM_EN6_N.n2 0.539857
R49 RXN.n0 RXN.t8 139.689
R50 RXN.n0 RXN.t9 139.689
R51 RXN.n1 RXN.n0 32.6024
R52 RXN.n2 RXN.t2 16.451
R53 RXN.n7 RXN.t6 15.7257
R54 RXN.n6 RXN.t1 15.7257
R55 RXN.n5 RXN.t0 15.7257
R56 RXN.n4 RXN.t3 15.7257
R57 RXN.n3 RXN.t4 15.7257
R58 RXN.n2 RXN.t5 15.641
R59 RXN.n1 RXN.t7 12.4583
R60 RXN.n3 RXN.n2 0.8105
R61 RXN.n4 RXN.n3 0.8105
R62 RXN.n5 RXN.n4 0.8105
R63 RXN.n6 RXN.n5 0.8105
R64 RXN.n7 RXN.n6 0.8105
R65 RXN RXN.n7 0.6305
R66 RXN RXN.n1 0.1805
R67 RXP.n0 RXP.t8 139.689
R68 RXP.n0 RXP.t9 139.689
R69 RXP.n1 RXP.n0 32.6024
R70 RXP.n2 RXP.t2 16.451
R71 RXP.n3 RXP.t7 15.7257
R72 RXP.n4 RXP.t6 15.7257
R73 RXP.n5 RXP.t1 15.7257
R74 RXP.n6 RXP.t3 15.7257
R75 RXP.n7 RXP.t4 15.7257
R76 RXP.n2 RXP.t0 15.641
R77 RXP.n1 RXP.t5 12.4583
R78 RXP.n3 RXP.n2 0.8105
R79 RXP.n4 RXP.n3 0.8105
R80 RXP.n5 RXP.n4 0.8105
R81 RXP.n6 RXP.n5 0.8105
R82 RXP.n7 RXP.n6 0.8105
R83 RXP RXP.n7 0.6305
R84 RXP RXP.n1 0.1805
R85 RX_BIAS.n4 RX_BIAS.t4 139.702
R86 RX_BIAS.n0 RX_BIAS.t0 139.702
R87 RX_BIAS.n15 RX_BIAS.t9 139.702
R88 RX_BIAS.n11 RX_BIAS.t5 139.702
R89 RX_BIAS.n1 RX_BIAS.t1 135.246
R90 RX_BIAS.n2 RX_BIAS.t2 135.246
R91 RX_BIAS.n3 RX_BIAS.t3 135.246
R92 RX_BIAS.n12 RX_BIAS.t6 135.246
R93 RX_BIAS.n13 RX_BIAS.t7 135.246
R94 RX_BIAS.n14 RX_BIAS.t8 135.246
R95 RX_BIAS.n6 RX_BIAS.t10 35.4171
R96 RX_BIAS.n9 RX_BIAS.t13 35.4171
R97 RX_BIAS.n7 RX_BIAS.t11 30.9603
R98 RX_BIAS.n8 RX_BIAS.t12 30.9603
R99 RX_BIAS.n17 RX_BIAS.n10 21.4384
R100 RX_BIAS.n18 RX_BIAS.n5 18.9479
R101 RX_BIAS.n5 RX_BIAS.n2 18.4942
R102 RX_BIAS.n16 RX_BIAS.n13 18.4942
R103 RX_BIAS.n17 RX_BIAS.n16 18.0005
R104 RX_BIAS.n8 RX_BIAS.n7 11.6805
R105 RX_BIAS.n2 RX_BIAS.n1 11.6805
R106 RX_BIAS.n3 RX_BIAS.n2 11.6805
R107 RX_BIAS.n13 RX_BIAS.n12 11.6805
R108 RX_BIAS.n14 RX_BIAS.n13 11.6805
R109 RX_BIAS RX_BIAS.n18 7.56892
R110 RX_BIAS.n5 RX_BIAS.n0 7.16487
R111 RX_BIAS.n5 RX_BIAS.n4 7.16487
R112 RX_BIAS.n16 RX_BIAS.n11 7.16487
R113 RX_BIAS.n16 RX_BIAS.n15 7.16487
R114 RX_BIAS.n10 RX_BIAS.n6 7.09873
R115 RX_BIAS.n10 RX_BIAS.n9 7.09873
R116 RX_BIAS.n7 RX_BIAS.n6 4.42851
R117 RX_BIAS.n9 RX_BIAS.n8 4.42851
R118 RX_BIAS.n1 RX_BIAS.n0 4.42851
R119 RX_BIAS.n4 RX_BIAS.n3 4.42851
R120 RX_BIAS.n12 RX_BIAS.n11 4.42851
R121 RX_BIAS.n15 RX_BIAS.n14 4.42851
R122 RX_BIAS.n18 RX_BIAS.n17 0.947868
R123 VTHN.n0 VTHN.t0 35.4171
R124 VTHN.n0 VTHN.t1 35.3883
R125 VTHN VTHN.n0 26.2142
R126 VTHP.n0 VTHP.t1 35.4171
R127 VTHP.n0 VTHP.t0 35.3883
R128 VTHP VTHP.n0 26.2142
R129 RX_BW_EN_N.n1 RX_BW_EN_N.t3 104.718
R130 RX_BW_EN_N.n0 RX_BW_EN_N.t0 104.718
R131 RX_BW_EN_N.n1 RX_BW_EN_N.t2 102.35
R132 RX_BW_EN_N.n0 RX_BW_EN_N.t1 102.35
R133 RX_BW_EN_N RX_BW_EN_N.n0 1.06629
R134 RX_BW_EN_N RX_BW_EN_N.n1 0.829447
R135 O_SENSE_BOOST.t23 O_SENSE_BOOST.n52 153.859
R136 O_SENSE_BOOST.t0 O_SENSE_BOOST.n23 153.859
R137 O_SENSE_BOOST.t13 O_SENSE_BOOST.n38 153.739
R138 O_SENSE_BOOST.t15 O_SENSE_BOOST.n62 153.739
R139 O_SENSE_BOOST.n61 O_SENSE_BOOST.t16 153.739
R140 O_SENSE_BOOST.n52 O_SENSE_BOOST.t22 153.739
R141 O_SENSE_BOOST.n51 O_SENSE_BOOST.t21 153.739
R142 O_SENSE_BOOST.n50 O_SENSE_BOOST.t20 153.739
R143 O_SENSE_BOOST.n49 O_SENSE_BOOST.t19 153.739
R144 O_SENSE_BOOST.t18 O_SENSE_BOOST.n43 153.739
R145 O_SENSE_BOOST.n60 O_SENSE_BOOST.t17 153.739
R146 O_SENSE_BOOST.t14 O_SENSE_BOOST.n0 153.739
R147 O_SENSE_BOOST.n23 O_SENSE_BOOST.t1 153.739
R148 O_SENSE_BOOST.n22 O_SENSE_BOOST.t2 153.739
R149 O_SENSE_BOOST.n21 O_SENSE_BOOST.t3 153.739
R150 O_SENSE_BOOST.n20 O_SENSE_BOOST.t4 153.739
R151 O_SENSE_BOOST.n19 O_SENSE_BOOST.t5 153.739
R152 O_SENSE_BOOST.n18 O_SENSE_BOOST.t6 153.739
R153 O_SENSE_BOOST.n17 O_SENSE_BOOST.t7 153.739
R154 O_SENSE_BOOST.n16 O_SENSE_BOOST.t8 153.739
R155 O_SENSE_BOOST.n15 O_SENSE_BOOST.t9 153.739
R156 O_SENSE_BOOST.t10 O_SENSE_BOOST.n3 153.739
R157 O_SENSE_BOOST.n36 O_SENSE_BOOST.t11 153.739
R158 O_SENSE_BOOST.n37 O_SENSE_BOOST.t12 153.739
R159 O_SENSE_BOOST.n53 O_SENSE_BOOST.t23 139.702
R160 O_SENSE_BOOST.n24 O_SENSE_BOOST.t0 139.702
R161 O_SENSE_BOOST.n39 O_SENSE_BOOST.t13 135.246
R162 O_SENSE_BOOST.n63 O_SENSE_BOOST.t15 135.246
R163 O_SENSE_BOOST.t16 O_SENSE_BOOST.n42 135.246
R164 O_SENSE_BOOST.n54 O_SENSE_BOOST.t22 135.246
R165 O_SENSE_BOOST.n55 O_SENSE_BOOST.t21 135.246
R166 O_SENSE_BOOST.n56 O_SENSE_BOOST.t20 135.246
R167 O_SENSE_BOOST.n57 O_SENSE_BOOST.t19 135.246
R168 O_SENSE_BOOST.n58 O_SENSE_BOOST.t18 135.246
R169 O_SENSE_BOOST.t17 O_SENSE_BOOST.n59 135.246
R170 O_SENSE_BOOST.n40 O_SENSE_BOOST.t14 135.246
R171 O_SENSE_BOOST.n25 O_SENSE_BOOST.t1 135.246
R172 O_SENSE_BOOST.n26 O_SENSE_BOOST.t2 135.246
R173 O_SENSE_BOOST.n27 O_SENSE_BOOST.t3 135.246
R174 O_SENSE_BOOST.n28 O_SENSE_BOOST.t4 135.246
R175 O_SENSE_BOOST.n29 O_SENSE_BOOST.t5 135.246
R176 O_SENSE_BOOST.n30 O_SENSE_BOOST.t6 135.246
R177 O_SENSE_BOOST.n31 O_SENSE_BOOST.t7 135.246
R178 O_SENSE_BOOST.n32 O_SENSE_BOOST.t8 135.246
R179 O_SENSE_BOOST.n33 O_SENSE_BOOST.t9 135.246
R180 O_SENSE_BOOST.n34 O_SENSE_BOOST.t10 135.246
R181 O_SENSE_BOOST.t11 O_SENSE_BOOST.n35 135.246
R182 O_SENSE_BOOST.t12 O_SENSE_BOOST.n2 135.246
R183 O_SENSE_BOOST O_SENSE_BOOST.n66 31.5205
R184 O_SENSE_BOOST.n39 O_SENSE_BOOST.n1 18.4942
R185 O_SENSE_BOOST.n64 O_SENSE_BOOST.n63 18.4942
R186 O_SENSE_BOOST.n42 O_SENSE_BOOST.n41 18.4942
R187 O_SENSE_BOOST.n55 O_SENSE_BOOST.n48 18.4942
R188 O_SENSE_BOOST.n56 O_SENSE_BOOST.n47 18.4942
R189 O_SENSE_BOOST.n57 O_SENSE_BOOST.n46 18.4942
R190 O_SENSE_BOOST.n58 O_SENSE_BOOST.n45 18.4942
R191 O_SENSE_BOOST.n59 O_SENSE_BOOST.n44 18.4942
R192 O_SENSE_BOOST.n65 O_SENSE_BOOST.n40 18.4942
R193 O_SENSE_BOOST.n26 O_SENSE_BOOST.n14 18.4942
R194 O_SENSE_BOOST.n27 O_SENSE_BOOST.n13 18.4942
R195 O_SENSE_BOOST.n28 O_SENSE_BOOST.n12 18.4942
R196 O_SENSE_BOOST.n29 O_SENSE_BOOST.n11 18.4942
R197 O_SENSE_BOOST.n30 O_SENSE_BOOST.n10 18.4942
R198 O_SENSE_BOOST.n31 O_SENSE_BOOST.n9 18.4942
R199 O_SENSE_BOOST.n32 O_SENSE_BOOST.n8 18.4942
R200 O_SENSE_BOOST.n33 O_SENSE_BOOST.n7 18.4942
R201 O_SENSE_BOOST.n34 O_SENSE_BOOST.n6 18.4942
R202 O_SENSE_BOOST.n35 O_SENSE_BOOST.n5 18.4942
R203 O_SENSE_BOOST.n4 O_SENSE_BOOST.n2 18.4942
R204 O_SENSE_BOOST.n63 O_SENSE_BOOST.n40 11.6805
R205 O_SENSE_BOOST.n63 O_SENSE_BOOST.n42 11.6805
R206 O_SENSE_BOOST.n55 O_SENSE_BOOST.n54 11.6805
R207 O_SENSE_BOOST.n56 O_SENSE_BOOST.n55 11.6805
R208 O_SENSE_BOOST.n57 O_SENSE_BOOST.n56 11.6805
R209 O_SENSE_BOOST.n58 O_SENSE_BOOST.n57 11.6805
R210 O_SENSE_BOOST.n59 O_SENSE_BOOST.n58 11.6805
R211 O_SENSE_BOOST.n59 O_SENSE_BOOST.n42 11.6805
R212 O_SENSE_BOOST.n40 O_SENSE_BOOST.n39 11.6805
R213 O_SENSE_BOOST.n26 O_SENSE_BOOST.n25 11.6805
R214 O_SENSE_BOOST.n27 O_SENSE_BOOST.n26 11.6805
R215 O_SENSE_BOOST.n28 O_SENSE_BOOST.n27 11.6805
R216 O_SENSE_BOOST.n29 O_SENSE_BOOST.n28 11.6805
R217 O_SENSE_BOOST.n30 O_SENSE_BOOST.n29 11.6805
R218 O_SENSE_BOOST.n31 O_SENSE_BOOST.n30 11.6805
R219 O_SENSE_BOOST.n32 O_SENSE_BOOST.n31 11.6805
R220 O_SENSE_BOOST.n33 O_SENSE_BOOST.n32 11.6805
R221 O_SENSE_BOOST.n34 O_SENSE_BOOST.n33 11.6805
R222 O_SENSE_BOOST.n35 O_SENSE_BOOST.n34 11.6805
R223 O_SENSE_BOOST.n35 O_SENSE_BOOST.n2 11.6805
R224 O_SENSE_BOOST.n39 O_SENSE_BOOST.n2 11.6805
R225 O_SENSE_BOOST.n66 O_SENSE_BOOST.n65 10.3505
R226 O_SENSE_BOOST.n66 O_SENSE_BOOST.n0 9.88093
R227 O_SENSE_BOOST.n53 O_SENSE_BOOST.n48 7.17687
R228 O_SENSE_BOOST.n24 O_SENSE_BOOST.n14 7.17687
R229 O_SENSE_BOOST.n54 O_SENSE_BOOST.n53 4.42851
R230 O_SENSE_BOOST.n25 O_SENSE_BOOST.n24 4.42851
R231 O_SENSE_BOOST.n4 O_SENSE_BOOST.n1 0.1205
R232 O_SENSE_BOOST.n5 O_SENSE_BOOST.n4 0.1205
R233 O_SENSE_BOOST.n6 O_SENSE_BOOST.n5 0.1205
R234 O_SENSE_BOOST.n7 O_SENSE_BOOST.n6 0.1205
R235 O_SENSE_BOOST.n8 O_SENSE_BOOST.n7 0.1205
R236 O_SENSE_BOOST.n9 O_SENSE_BOOST.n8 0.1205
R237 O_SENSE_BOOST.n10 O_SENSE_BOOST.n9 0.1205
R238 O_SENSE_BOOST.n11 O_SENSE_BOOST.n10 0.1205
R239 O_SENSE_BOOST.n12 O_SENSE_BOOST.n11 0.1205
R240 O_SENSE_BOOST.n13 O_SENSE_BOOST.n12 0.1205
R241 O_SENSE_BOOST.n14 O_SENSE_BOOST.n13 0.1205
R242 O_SENSE_BOOST.n38 O_SENSE_BOOST.n37 0.1205
R243 O_SENSE_BOOST.n37 O_SENSE_BOOST.n36 0.1205
R244 O_SENSE_BOOST.n36 O_SENSE_BOOST.n3 0.1205
R245 O_SENSE_BOOST.n15 O_SENSE_BOOST.n3 0.1205
R246 O_SENSE_BOOST.n16 O_SENSE_BOOST.n15 0.1205
R247 O_SENSE_BOOST.n17 O_SENSE_BOOST.n16 0.1205
R248 O_SENSE_BOOST.n18 O_SENSE_BOOST.n17 0.1205
R249 O_SENSE_BOOST.n19 O_SENSE_BOOST.n18 0.1205
R250 O_SENSE_BOOST.n20 O_SENSE_BOOST.n19 0.1205
R251 O_SENSE_BOOST.n21 O_SENSE_BOOST.n20 0.1205
R252 O_SENSE_BOOST.n22 O_SENSE_BOOST.n21 0.1205
R253 O_SENSE_BOOST.n23 O_SENSE_BOOST.n22 0.1205
R254 O_SENSE_BOOST.n52 O_SENSE_BOOST.n51 0.1205
R255 O_SENSE_BOOST.n51 O_SENSE_BOOST.n50 0.1205
R256 O_SENSE_BOOST.n50 O_SENSE_BOOST.n49 0.1205
R257 O_SENSE_BOOST.n49 O_SENSE_BOOST.n43 0.1205
R258 O_SENSE_BOOST.n60 O_SENSE_BOOST.n43 0.1205
R259 O_SENSE_BOOST.n61 O_SENSE_BOOST.n60 0.1205
R260 O_SENSE_BOOST.n62 O_SENSE_BOOST.n61 0.1205
R261 O_SENSE_BOOST.n48 O_SENSE_BOOST.n47 0.1205
R262 O_SENSE_BOOST.n47 O_SENSE_BOOST.n46 0.1205
R263 O_SENSE_BOOST.n46 O_SENSE_BOOST.n45 0.1205
R264 O_SENSE_BOOST.n45 O_SENSE_BOOST.n44 0.1205
R265 O_SENSE_BOOST.n44 O_SENSE_BOOST.n41 0.1205
R266 O_SENSE_BOOST.n64 O_SENSE_BOOST.n41 0.1205
R267 O_SENSE_BOOST.n65 O_SENSE_BOOST.n1 0.1085
R268 O_SENSE_BOOST.n38 O_SENSE_BOOST.n0 0.1085
R269 O_SENSE_BOOST.n62 O_SENSE_BOOST.n0 0.1085
R270 O_SENSE_BOOST.n65 O_SENSE_BOOST.n64 0.1085
R271 E_SENSE_BOOST.t23 E_SENSE_BOOST.n47 153.859
R272 E_SENSE_BOOST.t0 E_SENSE_BOOST.n13 153.859
R273 E_SENSE_BOOST.t8 E_SENSE_BOOST.n23 153.739
R274 E_SENSE_BOOST.t10 E_SENSE_BOOST.n62 153.739
R275 E_SENSE_BOOST.n61 E_SENSE_BOOST.t11 153.739
R276 E_SENSE_BOOST.n47 E_SENSE_BOOST.t22 153.739
R277 E_SENSE_BOOST.n46 E_SENSE_BOOST.t21 153.739
R278 E_SENSE_BOOST.n45 E_SENSE_BOOST.t20 153.739
R279 E_SENSE_BOOST.n44 E_SENSE_BOOST.t19 153.739
R280 E_SENSE_BOOST.n43 E_SENSE_BOOST.t18 153.739
R281 E_SENSE_BOOST.n42 E_SENSE_BOOST.t17 153.739
R282 E_SENSE_BOOST.n41 E_SENSE_BOOST.t16 153.739
R283 E_SENSE_BOOST.n40 E_SENSE_BOOST.t15 153.739
R284 E_SENSE_BOOST.n39 E_SENSE_BOOST.t14 153.739
R285 E_SENSE_BOOST.t13 E_SENSE_BOOST.n28 153.739
R286 E_SENSE_BOOST.n60 E_SENSE_BOOST.t12 153.739
R287 E_SENSE_BOOST.t9 E_SENSE_BOOST.n0 153.739
R288 E_SENSE_BOOST.n13 E_SENSE_BOOST.t1 153.739
R289 E_SENSE_BOOST.n12 E_SENSE_BOOST.t2 153.739
R290 E_SENSE_BOOST.n11 E_SENSE_BOOST.t3 153.739
R291 E_SENSE_BOOST.n10 E_SENSE_BOOST.t4 153.739
R292 E_SENSE_BOOST.t5 E_SENSE_BOOST.n3 153.739
R293 E_SENSE_BOOST.n21 E_SENSE_BOOST.t6 153.739
R294 E_SENSE_BOOST.n22 E_SENSE_BOOST.t7 153.739
R295 E_SENSE_BOOST.n48 E_SENSE_BOOST.t23 139.702
R296 E_SENSE_BOOST.n14 E_SENSE_BOOST.t0 139.702
R297 E_SENSE_BOOST.n24 E_SENSE_BOOST.t8 135.246
R298 E_SENSE_BOOST.n63 E_SENSE_BOOST.t10 135.246
R299 E_SENSE_BOOST.t11 E_SENSE_BOOST.n27 135.246
R300 E_SENSE_BOOST.n49 E_SENSE_BOOST.t22 135.246
R301 E_SENSE_BOOST.n50 E_SENSE_BOOST.t21 135.246
R302 E_SENSE_BOOST.n51 E_SENSE_BOOST.t20 135.246
R303 E_SENSE_BOOST.n52 E_SENSE_BOOST.t19 135.246
R304 E_SENSE_BOOST.n53 E_SENSE_BOOST.t18 135.246
R305 E_SENSE_BOOST.n54 E_SENSE_BOOST.t17 135.246
R306 E_SENSE_BOOST.n55 E_SENSE_BOOST.t16 135.246
R307 E_SENSE_BOOST.n56 E_SENSE_BOOST.t15 135.246
R308 E_SENSE_BOOST.n57 E_SENSE_BOOST.t14 135.246
R309 E_SENSE_BOOST.n58 E_SENSE_BOOST.t13 135.246
R310 E_SENSE_BOOST.t12 E_SENSE_BOOST.n59 135.246
R311 E_SENSE_BOOST.n25 E_SENSE_BOOST.t9 135.246
R312 E_SENSE_BOOST.n15 E_SENSE_BOOST.t1 135.246
R313 E_SENSE_BOOST.n16 E_SENSE_BOOST.t2 135.246
R314 E_SENSE_BOOST.n17 E_SENSE_BOOST.t3 135.246
R315 E_SENSE_BOOST.n18 E_SENSE_BOOST.t4 135.246
R316 E_SENSE_BOOST.n19 E_SENSE_BOOST.t5 135.246
R317 E_SENSE_BOOST.t6 E_SENSE_BOOST.n20 135.246
R318 E_SENSE_BOOST.t7 E_SENSE_BOOST.n2 135.246
R319 E_SENSE_BOOST E_SENSE_BOOST.n66 31.5205
R320 E_SENSE_BOOST.n24 E_SENSE_BOOST.n1 18.4942
R321 E_SENSE_BOOST.n64 E_SENSE_BOOST.n63 18.4942
R322 E_SENSE_BOOST.n27 E_SENSE_BOOST.n26 18.4942
R323 E_SENSE_BOOST.n50 E_SENSE_BOOST.n38 18.4942
R324 E_SENSE_BOOST.n51 E_SENSE_BOOST.n37 18.4942
R325 E_SENSE_BOOST.n52 E_SENSE_BOOST.n36 18.4942
R326 E_SENSE_BOOST.n53 E_SENSE_BOOST.n35 18.4942
R327 E_SENSE_BOOST.n54 E_SENSE_BOOST.n34 18.4942
R328 E_SENSE_BOOST.n55 E_SENSE_BOOST.n33 18.4942
R329 E_SENSE_BOOST.n56 E_SENSE_BOOST.n32 18.4942
R330 E_SENSE_BOOST.n57 E_SENSE_BOOST.n31 18.4942
R331 E_SENSE_BOOST.n58 E_SENSE_BOOST.n30 18.4942
R332 E_SENSE_BOOST.n59 E_SENSE_BOOST.n29 18.4942
R333 E_SENSE_BOOST.n65 E_SENSE_BOOST.n25 18.4942
R334 E_SENSE_BOOST.n16 E_SENSE_BOOST.n9 18.4942
R335 E_SENSE_BOOST.n17 E_SENSE_BOOST.n8 18.4942
R336 E_SENSE_BOOST.n18 E_SENSE_BOOST.n7 18.4942
R337 E_SENSE_BOOST.n19 E_SENSE_BOOST.n6 18.4942
R338 E_SENSE_BOOST.n20 E_SENSE_BOOST.n5 18.4942
R339 E_SENSE_BOOST.n4 E_SENSE_BOOST.n2 18.4942
R340 E_SENSE_BOOST.n63 E_SENSE_BOOST.n25 11.6805
R341 E_SENSE_BOOST.n63 E_SENSE_BOOST.n27 11.6805
R342 E_SENSE_BOOST.n50 E_SENSE_BOOST.n49 11.6805
R343 E_SENSE_BOOST.n51 E_SENSE_BOOST.n50 11.6805
R344 E_SENSE_BOOST.n52 E_SENSE_BOOST.n51 11.6805
R345 E_SENSE_BOOST.n53 E_SENSE_BOOST.n52 11.6805
R346 E_SENSE_BOOST.n54 E_SENSE_BOOST.n53 11.6805
R347 E_SENSE_BOOST.n55 E_SENSE_BOOST.n54 11.6805
R348 E_SENSE_BOOST.n56 E_SENSE_BOOST.n55 11.6805
R349 E_SENSE_BOOST.n57 E_SENSE_BOOST.n56 11.6805
R350 E_SENSE_BOOST.n58 E_SENSE_BOOST.n57 11.6805
R351 E_SENSE_BOOST.n59 E_SENSE_BOOST.n58 11.6805
R352 E_SENSE_BOOST.n59 E_SENSE_BOOST.n27 11.6805
R353 E_SENSE_BOOST.n25 E_SENSE_BOOST.n24 11.6805
R354 E_SENSE_BOOST.n16 E_SENSE_BOOST.n15 11.6805
R355 E_SENSE_BOOST.n17 E_SENSE_BOOST.n16 11.6805
R356 E_SENSE_BOOST.n18 E_SENSE_BOOST.n17 11.6805
R357 E_SENSE_BOOST.n19 E_SENSE_BOOST.n18 11.6805
R358 E_SENSE_BOOST.n20 E_SENSE_BOOST.n19 11.6805
R359 E_SENSE_BOOST.n20 E_SENSE_BOOST.n2 11.6805
R360 E_SENSE_BOOST.n24 E_SENSE_BOOST.n2 11.6805
R361 E_SENSE_BOOST.n66 E_SENSE_BOOST.n65 10.3505
R362 E_SENSE_BOOST.n66 E_SENSE_BOOST.n0 9.88093
R363 E_SENSE_BOOST.n48 E_SENSE_BOOST.n38 7.17687
R364 E_SENSE_BOOST.n14 E_SENSE_BOOST.n9 7.17687
R365 E_SENSE_BOOST.n49 E_SENSE_BOOST.n48 4.42851
R366 E_SENSE_BOOST.n15 E_SENSE_BOOST.n14 4.42851
R367 E_SENSE_BOOST.n4 E_SENSE_BOOST.n1 0.1205
R368 E_SENSE_BOOST.n5 E_SENSE_BOOST.n4 0.1205
R369 E_SENSE_BOOST.n6 E_SENSE_BOOST.n5 0.1205
R370 E_SENSE_BOOST.n7 E_SENSE_BOOST.n6 0.1205
R371 E_SENSE_BOOST.n8 E_SENSE_BOOST.n7 0.1205
R372 E_SENSE_BOOST.n9 E_SENSE_BOOST.n8 0.1205
R373 E_SENSE_BOOST.n23 E_SENSE_BOOST.n22 0.1205
R374 E_SENSE_BOOST.n22 E_SENSE_BOOST.n21 0.1205
R375 E_SENSE_BOOST.n21 E_SENSE_BOOST.n3 0.1205
R376 E_SENSE_BOOST.n10 E_SENSE_BOOST.n3 0.1205
R377 E_SENSE_BOOST.n11 E_SENSE_BOOST.n10 0.1205
R378 E_SENSE_BOOST.n12 E_SENSE_BOOST.n11 0.1205
R379 E_SENSE_BOOST.n13 E_SENSE_BOOST.n12 0.1205
R380 E_SENSE_BOOST.n47 E_SENSE_BOOST.n46 0.1205
R381 E_SENSE_BOOST.n46 E_SENSE_BOOST.n45 0.1205
R382 E_SENSE_BOOST.n45 E_SENSE_BOOST.n44 0.1205
R383 E_SENSE_BOOST.n44 E_SENSE_BOOST.n43 0.1205
R384 E_SENSE_BOOST.n43 E_SENSE_BOOST.n42 0.1205
R385 E_SENSE_BOOST.n42 E_SENSE_BOOST.n41 0.1205
R386 E_SENSE_BOOST.n41 E_SENSE_BOOST.n40 0.1205
R387 E_SENSE_BOOST.n40 E_SENSE_BOOST.n39 0.1205
R388 E_SENSE_BOOST.n39 E_SENSE_BOOST.n28 0.1205
R389 E_SENSE_BOOST.n60 E_SENSE_BOOST.n28 0.1205
R390 E_SENSE_BOOST.n61 E_SENSE_BOOST.n60 0.1205
R391 E_SENSE_BOOST.n62 E_SENSE_BOOST.n61 0.1205
R392 E_SENSE_BOOST.n38 E_SENSE_BOOST.n37 0.1205
R393 E_SENSE_BOOST.n37 E_SENSE_BOOST.n36 0.1205
R394 E_SENSE_BOOST.n36 E_SENSE_BOOST.n35 0.1205
R395 E_SENSE_BOOST.n35 E_SENSE_BOOST.n34 0.1205
R396 E_SENSE_BOOST.n34 E_SENSE_BOOST.n33 0.1205
R397 E_SENSE_BOOST.n33 E_SENSE_BOOST.n32 0.1205
R398 E_SENSE_BOOST.n32 E_SENSE_BOOST.n31 0.1205
R399 E_SENSE_BOOST.n31 E_SENSE_BOOST.n30 0.1205
R400 E_SENSE_BOOST.n30 E_SENSE_BOOST.n29 0.1205
R401 E_SENSE_BOOST.n29 E_SENSE_BOOST.n26 0.1205
R402 E_SENSE_BOOST.n64 E_SENSE_BOOST.n26 0.1205
R403 E_SENSE_BOOST.n65 E_SENSE_BOOST.n1 0.1085
R404 E_SENSE_BOOST.n23 E_SENSE_BOOST.n0 0.1085
R405 E_SENSE_BOOST.n62 E_SENSE_BOOST.n0 0.1085
R406 E_SENSE_BOOST.n65 E_SENSE_BOOST.n64 0.1085
R407 RX_RAWN.t4 RX_RAWN.n7 127.788
R408 RX_RAWN.t12 RX_RAWN.n27 127.788
R409 RX_RAWN.t11 RX_RAWN.n0 127.776
R410 RX_RAWN.t19 RX_RAWN.n20 127.776
R411 RX_RAWN.t9 RX_RAWN.n14 127.668
R412 RX_RAWN.t10 RX_RAWN.n0 127.668
R413 RX_RAWN.n7 RX_RAWN.t5 127.668
R414 RX_RAWN.t6 RX_RAWN.n3 127.668
R415 RX_RAWN.n12 RX_RAWN.t7 127.668
R416 RX_RAWN.n13 RX_RAWN.t8 127.668
R417 RX_RAWN.t17 RX_RAWN.n34 127.668
R418 RX_RAWN.t18 RX_RAWN.n20 127.668
R419 RX_RAWN.n27 RX_RAWN.t13 127.668
R420 RX_RAWN.t14 RX_RAWN.n23 127.668
R421 RX_RAWN.n32 RX_RAWN.t15 127.668
R422 RX_RAWN.n33 RX_RAWN.t16 127.668
R423 RX_RAWN.n8 RX_RAWN.t4 113.632
R424 RX_RAWN.n28 RX_RAWN.t12 113.632
R425 RX_RAWN.n17 RX_RAWN.t11 113.629
R426 RX_RAWN.n37 RX_RAWN.t19 113.629
R427 RX_RAWN.n15 RX_RAWN.t9 109.174
R428 RX_RAWN.n16 RX_RAWN.t10 109.174
R429 RX_RAWN.n9 RX_RAWN.t5 109.174
R430 RX_RAWN.n10 RX_RAWN.t6 109.174
R431 RX_RAWN.t7 RX_RAWN.n11 109.174
R432 RX_RAWN.t8 RX_RAWN.n2 109.174
R433 RX_RAWN.n35 RX_RAWN.t17 109.174
R434 RX_RAWN.n36 RX_RAWN.t18 109.174
R435 RX_RAWN.n29 RX_RAWN.t13 109.174
R436 RX_RAWN.n30 RX_RAWN.t14 109.174
R437 RX_RAWN.t15 RX_RAWN.n31 109.174
R438 RX_RAWN.t16 RX_RAWN.n22 109.174
R439 RX_RAWN.n40 RX_RAWN.n19 48.1811
R440 RX_RAWN.n40 RX_RAWN.n39 45.4727
R441 RX_RAWN.n15 RX_RAWN.n1 18.4942
R442 RX_RAWN.n10 RX_RAWN.n6 18.4942
R443 RX_RAWN.n11 RX_RAWN.n5 18.4942
R444 RX_RAWN.n4 RX_RAWN.n2 18.4942
R445 RX_RAWN.n35 RX_RAWN.n21 18.4942
R446 RX_RAWN.n30 RX_RAWN.n26 18.4942
R447 RX_RAWN.n31 RX_RAWN.n25 18.4942
R448 RX_RAWN.n24 RX_RAWN.n22 18.4942
R449 RX_RAWN.n43 RX_RAWN.t1 12.3293
R450 RX_RAWN.n16 RX_RAWN.n15 11.6805
R451 RX_RAWN.n10 RX_RAWN.n9 11.6805
R452 RX_RAWN.n11 RX_RAWN.n10 11.6805
R453 RX_RAWN.n11 RX_RAWN.n2 11.6805
R454 RX_RAWN.n15 RX_RAWN.n2 11.6805
R455 RX_RAWN.n36 RX_RAWN.n35 11.6805
R456 RX_RAWN.n30 RX_RAWN.n29 11.6805
R457 RX_RAWN.n31 RX_RAWN.n30 11.6805
R458 RX_RAWN.n31 RX_RAWN.n22 11.6805
R459 RX_RAWN.n35 RX_RAWN.n22 11.6805
R460 RX_RAWN.n19 RX_RAWN.n0 10.8396
R461 RX_RAWN.n39 RX_RAWN.n20 10.8396
R462 RX_RAWN.n42 RX_RAWN.t2 10.6142
R463 RX_RAWN.n19 RX_RAWN.n18 9.0005
R464 RX_RAWN.n39 RX_RAWN.n38 9.0005
R465 RX_RAWN.n8 RX_RAWN.n6 7.17687
R466 RX_RAWN.n28 RX_RAWN.n26 7.17687
R467 RX_RAWN.n18 RX_RAWN.n17 7.05405
R468 RX_RAWN.n38 RX_RAWN.n37 7.05405
R469 RX_RAWN.n41 RX_RAWN.t0 6.0676
R470 RX_RAWN.n41 RX_RAWN.t3 6.06436
R471 RX_RAWN.n17 RX_RAWN.n16 4.4296
R472 RX_RAWN.n37 RX_RAWN.n36 4.4296
R473 RX_RAWN.n9 RX_RAWN.n8 4.42851
R474 RX_RAWN.n29 RX_RAWN.n28 4.42851
R475 RX_RAWN.n42 RX_RAWN.n41 3.78254
R476 RX_RAWN RX_RAWN.n40 2.56076
R477 RX_RAWN RX_RAWN.n43 1.52901
R478 RX_RAWN.n43 RX_RAWN.n42 0.733182
R479 RX_RAWN.n4 RX_RAWN.n1 0.1205
R480 RX_RAWN.n5 RX_RAWN.n4 0.1205
R481 RX_RAWN.n6 RX_RAWN.n5 0.1205
R482 RX_RAWN.n14 RX_RAWN.n13 0.1205
R483 RX_RAWN.n13 RX_RAWN.n12 0.1205
R484 RX_RAWN.n12 RX_RAWN.n3 0.1205
R485 RX_RAWN.n7 RX_RAWN.n3 0.1205
R486 RX_RAWN.n24 RX_RAWN.n21 0.1205
R487 RX_RAWN.n25 RX_RAWN.n24 0.1205
R488 RX_RAWN.n26 RX_RAWN.n25 0.1205
R489 RX_RAWN.n34 RX_RAWN.n33 0.1205
R490 RX_RAWN.n33 RX_RAWN.n32 0.1205
R491 RX_RAWN.n32 RX_RAWN.n23 0.1205
R492 RX_RAWN.n27 RX_RAWN.n23 0.1205
R493 RX_RAWN.n18 RX_RAWN.n1 0.1085
R494 RX_RAWN.n14 RX_RAWN.n0 0.1085
R495 RX_RAWN.n38 RX_RAWN.n21 0.1085
R496 RX_RAWN.n34 RX_RAWN.n20 0.1085
R497 RX_RAWP.t19 RX_RAWP.n28 127.788
R498 RX_RAWP.t11 RX_RAWP.n10 127.788
R499 RX_RAWP.t12 RX_RAWP.n20 127.776
R500 RX_RAWP.t4 RX_RAWP.n0 127.776
R501 RX_RAWP.t14 RX_RAWP.n35 127.668
R502 RX_RAWP.n34 RX_RAWP.t15 127.668
R503 RX_RAWP.n28 RX_RAWP.t18 127.668
R504 RX_RAWP.t17 RX_RAWP.n25 127.668
R505 RX_RAWP.n33 RX_RAWP.t16 127.668
R506 RX_RAWP.t13 RX_RAWP.n20 127.668
R507 RX_RAWP.n10 RX_RAWP.t10 127.668
R508 RX_RAWP.n9 RX_RAWP.t9 127.668
R509 RX_RAWP.n8 RX_RAWP.t8 127.668
R510 RX_RAWP.n7 RX_RAWP.t7 127.668
R511 RX_RAWP.n6 RX_RAWP.t6 127.668
R512 RX_RAWP.t5 RX_RAWP.n0 127.668
R513 RX_RAWP.n29 RX_RAWP.t19 113.632
R514 RX_RAWP.n11 RX_RAWP.t11 113.632
R515 RX_RAWP.n21 RX_RAWP.t12 113.629
R516 RX_RAWP.n1 RX_RAWP.t4 113.629
R517 RX_RAWP.n36 RX_RAWP.t14 109.174
R518 RX_RAWP.t15 RX_RAWP.n23 109.174
R519 RX_RAWP.n30 RX_RAWP.t18 109.174
R520 RX_RAWP.n31 RX_RAWP.t17 109.174
R521 RX_RAWP.t16 RX_RAWP.n32 109.174
R522 RX_RAWP.n24 RX_RAWP.t13 109.174
R523 RX_RAWP.t10 RX_RAWP.n5 109.174
R524 RX_RAWP.n13 RX_RAWP.t9 109.174
R525 RX_RAWP.n14 RX_RAWP.t8 109.174
R526 RX_RAWP.n15 RX_RAWP.t7 109.174
R527 RX_RAWP.n16 RX_RAWP.t6 109.174
R528 RX_RAWP.n3 RX_RAWP.t5 109.174
R529 RX_RAWP.n40 RX_RAWP.n39 43.7808
R530 RX_RAWP.n40 RX_RAWP.n19 42.2566
R531 RX_RAWP.n37 RX_RAWP.n36 18.4942
R532 RX_RAWP.n23 RX_RAWP.n22 18.4942
R533 RX_RAWP.n31 RX_RAWP.n27 18.4942
R534 RX_RAWP.n32 RX_RAWP.n26 18.4942
R535 RX_RAWP.n13 RX_RAWP.n12 18.4942
R536 RX_RAWP.n14 RX_RAWP.n4 18.4942
R537 RX_RAWP.n15 RX_RAWP.n2 18.4942
R538 RX_RAWP.n17 RX_RAWP.n16 18.4942
R539 RX_RAWP.n43 RX_RAWP.t0 12.5711
R540 RX_RAWP.n36 RX_RAWP.n24 11.6805
R541 RX_RAWP.n36 RX_RAWP.n23 11.6805
R542 RX_RAWP.n31 RX_RAWP.n30 11.6805
R543 RX_RAWP.n32 RX_RAWP.n31 11.6805
R544 RX_RAWP.n32 RX_RAWP.n23 11.6805
R545 RX_RAWP.n14 RX_RAWP.n13 11.6805
R546 RX_RAWP.n13 RX_RAWP.n5 11.6805
R547 RX_RAWP.n15 RX_RAWP.n14 11.6805
R548 RX_RAWP.n16 RX_RAWP.n15 11.6805
R549 RX_RAWP.n16 RX_RAWP.n3 11.6805
R550 RX_RAWP.n39 RX_RAWP.n20 10.8396
R551 RX_RAWP.n19 RX_RAWP.n0 10.8396
R552 RX_RAWP.n42 RX_RAWP.t1 10.6142
R553 RX_RAWP.n39 RX_RAWP.n38 9.0005
R554 RX_RAWP.n19 RX_RAWP.n18 9.0005
R555 RX_RAWP.n29 RX_RAWP.n27 7.17687
R556 RX_RAWP.n12 RX_RAWP.n11 7.17687
R557 RX_RAWP.n38 RX_RAWP.n21 7.05405
R558 RX_RAWP.n18 RX_RAWP.n1 7.05405
R559 RX_RAWP RX_RAWP.n43 6.39524
R560 RX_RAWP.n41 RX_RAWP.t3 6.0676
R561 RX_RAWP.n41 RX_RAWP.t2 6.06436
R562 RX_RAWP.n24 RX_RAWP.n21 4.4296
R563 RX_RAWP.n3 RX_RAWP.n1 4.4296
R564 RX_RAWP.n30 RX_RAWP.n29 4.42851
R565 RX_RAWP.n11 RX_RAWP.n5 4.42851
R566 RX_RAWP.n42 RX_RAWP.n41 3.78254
R567 RX_RAWP RX_RAWP.n40 1.37655
R568 RX_RAWP.n43 RX_RAWP.n42 0.491409
R569 RX_RAWP.n28 RX_RAWP.n25 0.1205
R570 RX_RAWP.n33 RX_RAWP.n25 0.1205
R571 RX_RAWP.n34 RX_RAWP.n33 0.1205
R572 RX_RAWP.n35 RX_RAWP.n34 0.1205
R573 RX_RAWP.n27 RX_RAWP.n26 0.1205
R574 RX_RAWP.n26 RX_RAWP.n22 0.1205
R575 RX_RAWP.n37 RX_RAWP.n22 0.1205
R576 RX_RAWP.n10 RX_RAWP.n9 0.1205
R577 RX_RAWP.n9 RX_RAWP.n8 0.1205
R578 RX_RAWP.n8 RX_RAWP.n7 0.1205
R579 RX_RAWP.n7 RX_RAWP.n6 0.1205
R580 RX_RAWP.n12 RX_RAWP.n4 0.1205
R581 RX_RAWP.n4 RX_RAWP.n2 0.1205
R582 RX_RAWP.n17 RX_RAWP.n2 0.1205
R583 RX_RAWP.n35 RX_RAWP.n20 0.1085
R584 RX_RAWP.n38 RX_RAWP.n37 0.1085
R585 RX_RAWP.n6 RX_RAWP.n0 0.1085
R586 RX_RAWP.n18 RX_RAWP.n17 0.1085
R587 O_SENSE_CLK.n58 O_SENSE_CLK.t0 139.702
R588 O_SENSE_CLK.n60 O_SENSE_CLK.t2 135.246
R589 O_SENSE_CLK.n61 O_SENSE_CLK.t3 135.246
R590 O_SENSE_CLK.n62 O_SENSE_CLK.t4 135.246
R591 O_SENSE_CLK.n57 O_SENSE_CLK.t1 135.246
R592 O_SENSE_CLK.t14 O_SENSE_CLK.n8 127.788
R593 O_SENSE_CLK.t26 O_SENSE_CLK.n45 127.788
R594 O_SENSE_CLK.t31 O_SENSE_CLK.n87 127.788
R595 O_SENSE_CLK.t19 O_SENSE_CLK.n35 127.776
R596 O_SENSE_CLK.t5 O_SENSE_CLK.n0 127.668
R597 O_SENSE_CLK.t6 O_SENSE_CLK.n23 127.668
R598 O_SENSE_CLK.n22 O_SENSE_CLK.t7 127.668
R599 O_SENSE_CLK.n21 O_SENSE_CLK.t8 127.668
R600 O_SENSE_CLK.t9 O_SENSE_CLK.n3 127.668
R601 O_SENSE_CLK.t10 O_SENSE_CLK.n15 127.668
R602 O_SENSE_CLK.n14 O_SENSE_CLK.t11 127.668
R603 O_SENSE_CLK.n13 O_SENSE_CLK.t12 127.668
R604 O_SENSE_CLK.t13 O_SENSE_CLK.n8 127.668
R605 O_SENSE_CLK.n45 O_SENSE_CLK.t25 127.668
R606 O_SENSE_CLK.n44 O_SENSE_CLK.t24 127.668
R607 O_SENSE_CLK.n43 O_SENSE_CLK.t23 127.668
R608 O_SENSE_CLK.n42 O_SENSE_CLK.t22 127.668
R609 O_SENSE_CLK.n41 O_SENSE_CLK.t21 127.668
R610 O_SENSE_CLK.t20 O_SENSE_CLK.n35 127.668
R611 O_SENSE_CLK.t40 O_SENSE_CLK.n72 127.668
R612 O_SENSE_CLK.n87 O_SENSE_CLK.t32 127.668
R613 O_SENSE_CLK.n86 O_SENSE_CLK.t33 127.668
R614 O_SENSE_CLK.n85 O_SENSE_CLK.t34 127.668
R615 O_SENSE_CLK.n84 O_SENSE_CLK.t35 127.668
R616 O_SENSE_CLK.n83 O_SENSE_CLK.t36 127.668
R617 O_SENSE_CLK.n82 O_SENSE_CLK.t37 127.668
R618 O_SENSE_CLK.n81 O_SENSE_CLK.t38 127.668
R619 O_SENSE_CLK.n80 O_SENSE_CLK.t39 127.668
R620 O_SENSE_CLK.n29 O_SENSE_CLK.t18 113.632
R621 O_SENSE_CLK.n10 O_SENSE_CLK.t14 113.632
R622 O_SENSE_CLK.n66 O_SENSE_CLK.t30 113.632
R623 O_SENSE_CLK.n46 O_SENSE_CLK.t26 113.632
R624 O_SENSE_CLK.n88 O_SENSE_CLK.t31 113.632
R625 O_SENSE_CLK.n36 O_SENSE_CLK.t19 113.629
R626 O_SENSE_CLK.n30 O_SENSE_CLK.t17 109.174
R627 O_SENSE_CLK.n31 O_SENSE_CLK.t16 109.174
R628 O_SENSE_CLK.n28 O_SENSE_CLK.t15 109.174
R629 O_SENSE_CLK.n25 O_SENSE_CLK.t5 109.174
R630 O_SENSE_CLK.n24 O_SENSE_CLK.t6 109.174
R631 O_SENSE_CLK.t7 O_SENSE_CLK.n2 109.174
R632 O_SENSE_CLK.t8 O_SENSE_CLK.n20 109.174
R633 O_SENSE_CLK.n4 O_SENSE_CLK.t9 109.174
R634 O_SENSE_CLK.n16 O_SENSE_CLK.t10 109.174
R635 O_SENSE_CLK.t11 O_SENSE_CLK.n7 109.174
R636 O_SENSE_CLK.t12 O_SENSE_CLK.n12 109.174
R637 O_SENSE_CLK.n9 O_SENSE_CLK.t13 109.174
R638 O_SENSE_CLK.n67 O_SENSE_CLK.t29 109.174
R639 O_SENSE_CLK.n68 O_SENSE_CLK.t28 109.174
R640 O_SENSE_CLK.n65 O_SENSE_CLK.t27 109.174
R641 O_SENSE_CLK.t25 O_SENSE_CLK.n40 109.174
R642 O_SENSE_CLK.n48 O_SENSE_CLK.t24 109.174
R643 O_SENSE_CLK.n49 O_SENSE_CLK.t23 109.174
R644 O_SENSE_CLK.n50 O_SENSE_CLK.t22 109.174
R645 O_SENSE_CLK.n51 O_SENSE_CLK.t21 109.174
R646 O_SENSE_CLK.n38 O_SENSE_CLK.t20 109.174
R647 O_SENSE_CLK.n97 O_SENSE_CLK.t40 109.174
R648 O_SENSE_CLK.n89 O_SENSE_CLK.t32 109.174
R649 O_SENSE_CLK.n90 O_SENSE_CLK.t33 109.174
R650 O_SENSE_CLK.n91 O_SENSE_CLK.t34 109.174
R651 O_SENSE_CLK.n92 O_SENSE_CLK.t35 109.174
R652 O_SENSE_CLK.n93 O_SENSE_CLK.t36 109.174
R653 O_SENSE_CLK.n94 O_SENSE_CLK.t37 109.174
R654 O_SENSE_CLK.n95 O_SENSE_CLK.t38 109.174
R655 O_SENSE_CLK.n96 O_SENSE_CLK.t39 109.174
R656 O_SENSE_CLK.n34 O_SENSE_CLK.n33 24.5548
R657 O_SENSE_CLK.n71 O_SENSE_CLK.n70 24.5548
R658 O_SENSE_CLK.n34 O_SENSE_CLK.n27 20.0548
R659 O_SENSE_CLK.n63 O_SENSE_CLK.n62 18.5723
R660 O_SENSE_CLK.n33 O_SENSE_CLK.n28 18.5179
R661 O_SENSE_CLK.n70 O_SENSE_CLK.n65 18.5179
R662 O_SENSE_CLK.n32 O_SENSE_CLK.n31 18.4942
R663 O_SENSE_CLK.n60 O_SENSE_CLK.n59 18.4942
R664 O_SENSE_CLK.n61 O_SENSE_CLK.n56 18.4942
R665 O_SENSE_CLK.n26 O_SENSE_CLK.n25 18.4942
R666 O_SENSE_CLK.n24 O_SENSE_CLK.n1 18.4942
R667 O_SENSE_CLK.n5 O_SENSE_CLK.n2 18.4942
R668 O_SENSE_CLK.n20 O_SENSE_CLK.n19 18.4942
R669 O_SENSE_CLK.n18 O_SENSE_CLK.n4 18.4942
R670 O_SENSE_CLK.n17 O_SENSE_CLK.n16 18.4942
R671 O_SENSE_CLK.n7 O_SENSE_CLK.n6 18.4942
R672 O_SENSE_CLK.n12 O_SENSE_CLK.n11 18.4942
R673 O_SENSE_CLK.n69 O_SENSE_CLK.n68 18.4942
R674 O_SENSE_CLK.n48 O_SENSE_CLK.n47 18.4942
R675 O_SENSE_CLK.n49 O_SENSE_CLK.n39 18.4942
R676 O_SENSE_CLK.n50 O_SENSE_CLK.n37 18.4942
R677 O_SENSE_CLK.n52 O_SENSE_CLK.n51 18.4942
R678 O_SENSE_CLK.n98 O_SENSE_CLK.n97 18.4942
R679 O_SENSE_CLK.n90 O_SENSE_CLK.n79 18.4942
R680 O_SENSE_CLK.n91 O_SENSE_CLK.n78 18.4942
R681 O_SENSE_CLK.n92 O_SENSE_CLK.n77 18.4942
R682 O_SENSE_CLK.n93 O_SENSE_CLK.n76 18.4942
R683 O_SENSE_CLK.n94 O_SENSE_CLK.n75 18.4942
R684 O_SENSE_CLK.n95 O_SENSE_CLK.n74 18.4942
R685 O_SENSE_CLK.n96 O_SENSE_CLK.n73 18.4942
R686 O_SENSE_CLK.n55 O_SENSE_CLK.n54 15.5548
R687 O_SENSE_CLK.n100 O_SENSE_CLK.n99 15.5548
R688 O_SENSE_CLK.n64 O_SENSE_CLK.n63 14.5766
R689 O_SENSE_CLK O_SENSE_CLK.n100 13.9118
R690 O_SENSE_CLK.n31 O_SENSE_CLK.n30 11.6805
R691 O_SENSE_CLK.n31 O_SENSE_CLK.n28 11.6805
R692 O_SENSE_CLK.n60 O_SENSE_CLK.n57 11.6805
R693 O_SENSE_CLK.n61 O_SENSE_CLK.n60 11.6805
R694 O_SENSE_CLK.n62 O_SENSE_CLK.n61 11.6805
R695 O_SENSE_CLK.n25 O_SENSE_CLK.n24 11.6805
R696 O_SENSE_CLK.n24 O_SENSE_CLK.n2 11.6805
R697 O_SENSE_CLK.n20 O_SENSE_CLK.n2 11.6805
R698 O_SENSE_CLK.n20 O_SENSE_CLK.n4 11.6805
R699 O_SENSE_CLK.n16 O_SENSE_CLK.n4 11.6805
R700 O_SENSE_CLK.n16 O_SENSE_CLK.n7 11.6805
R701 O_SENSE_CLK.n12 O_SENSE_CLK.n7 11.6805
R702 O_SENSE_CLK.n12 O_SENSE_CLK.n9 11.6805
R703 O_SENSE_CLK.n68 O_SENSE_CLK.n67 11.6805
R704 O_SENSE_CLK.n68 O_SENSE_CLK.n65 11.6805
R705 O_SENSE_CLK.n49 O_SENSE_CLK.n48 11.6805
R706 O_SENSE_CLK.n48 O_SENSE_CLK.n40 11.6805
R707 O_SENSE_CLK.n50 O_SENSE_CLK.n49 11.6805
R708 O_SENSE_CLK.n51 O_SENSE_CLK.n50 11.6805
R709 O_SENSE_CLK.n51 O_SENSE_CLK.n38 11.6805
R710 O_SENSE_CLK.n90 O_SENSE_CLK.n89 11.6805
R711 O_SENSE_CLK.n91 O_SENSE_CLK.n90 11.6805
R712 O_SENSE_CLK.n92 O_SENSE_CLK.n91 11.6805
R713 O_SENSE_CLK.n93 O_SENSE_CLK.n92 11.6805
R714 O_SENSE_CLK.n94 O_SENSE_CLK.n93 11.6805
R715 O_SENSE_CLK.n95 O_SENSE_CLK.n94 11.6805
R716 O_SENSE_CLK.n96 O_SENSE_CLK.n95 11.6805
R717 O_SENSE_CLK.n97 O_SENSE_CLK.n96 11.6805
R718 O_SENSE_CLK.n27 O_SENSE_CLK.n0 11.1876
R719 O_SENSE_CLK.n99 O_SENSE_CLK.n72 11.0376
R720 O_SENSE_CLK.n54 O_SENSE_CLK.n35 10.8396
R721 O_SENSE_CLK.n27 O_SENSE_CLK.n26 9.3485
R722 O_SENSE_CLK.n99 O_SENSE_CLK.n98 9.1985
R723 O_SENSE_CLK.n54 O_SENSE_CLK.n53 9.0005
R724 O_SENSE_CLK.n32 O_SENSE_CLK.n29 7.17687
R725 O_SENSE_CLK.n59 O_SENSE_CLK.n58 7.17687
R726 O_SENSE_CLK.n11 O_SENSE_CLK.n10 7.17687
R727 O_SENSE_CLK.n69 O_SENSE_CLK.n66 7.17687
R728 O_SENSE_CLK.n47 O_SENSE_CLK.n46 7.17687
R729 O_SENSE_CLK.n88 O_SENSE_CLK.n79 7.17687
R730 O_SENSE_CLK.n53 O_SENSE_CLK.n36 7.05405
R731 O_SENSE_CLK.n100 O_SENSE_CLK.n71 4.69615
R732 O_SENSE_CLK.n38 O_SENSE_CLK.n36 4.4296
R733 O_SENSE_CLK.n30 O_SENSE_CLK.n29 4.42851
R734 O_SENSE_CLK.n58 O_SENSE_CLK.n57 4.42851
R735 O_SENSE_CLK.n10 O_SENSE_CLK.n9 4.42851
R736 O_SENSE_CLK.n67 O_SENSE_CLK.n66 4.42851
R737 O_SENSE_CLK.n46 O_SENSE_CLK.n40 4.42851
R738 O_SENSE_CLK.n89 O_SENSE_CLK.n88 4.42851
R739 O_SENSE_CLK.n55 O_SENSE_CLK.n34 3.32659
R740 O_SENSE_CLK.n71 O_SENSE_CLK.n64 2.73963
R741 O_SENSE_CLK.n64 O_SENSE_CLK.n55 0.978761
R742 O_SENSE_CLK.n11 O_SENSE_CLK.n6 0.1205
R743 O_SENSE_CLK.n17 O_SENSE_CLK.n6 0.1205
R744 O_SENSE_CLK.n18 O_SENSE_CLK.n17 0.1205
R745 O_SENSE_CLK.n19 O_SENSE_CLK.n18 0.1205
R746 O_SENSE_CLK.n19 O_SENSE_CLK.n5 0.1205
R747 O_SENSE_CLK.n5 O_SENSE_CLK.n1 0.1205
R748 O_SENSE_CLK.n26 O_SENSE_CLK.n1 0.1205
R749 O_SENSE_CLK.n13 O_SENSE_CLK.n8 0.1205
R750 O_SENSE_CLK.n14 O_SENSE_CLK.n13 0.1205
R751 O_SENSE_CLK.n15 O_SENSE_CLK.n14 0.1205
R752 O_SENSE_CLK.n15 O_SENSE_CLK.n3 0.1205
R753 O_SENSE_CLK.n21 O_SENSE_CLK.n3 0.1205
R754 O_SENSE_CLK.n22 O_SENSE_CLK.n21 0.1205
R755 O_SENSE_CLK.n23 O_SENSE_CLK.n22 0.1205
R756 O_SENSE_CLK.n23 O_SENSE_CLK.n0 0.1205
R757 O_SENSE_CLK.n45 O_SENSE_CLK.n44 0.1205
R758 O_SENSE_CLK.n44 O_SENSE_CLK.n43 0.1205
R759 O_SENSE_CLK.n43 O_SENSE_CLK.n42 0.1205
R760 O_SENSE_CLK.n42 O_SENSE_CLK.n41 0.1205
R761 O_SENSE_CLK.n47 O_SENSE_CLK.n39 0.1205
R762 O_SENSE_CLK.n39 O_SENSE_CLK.n37 0.1205
R763 O_SENSE_CLK.n52 O_SENSE_CLK.n37 0.1205
R764 O_SENSE_CLK.n98 O_SENSE_CLK.n73 0.1205
R765 O_SENSE_CLK.n74 O_SENSE_CLK.n73 0.1205
R766 O_SENSE_CLK.n75 O_SENSE_CLK.n74 0.1205
R767 O_SENSE_CLK.n76 O_SENSE_CLK.n75 0.1205
R768 O_SENSE_CLK.n77 O_SENSE_CLK.n76 0.1205
R769 O_SENSE_CLK.n78 O_SENSE_CLK.n77 0.1205
R770 O_SENSE_CLK.n79 O_SENSE_CLK.n78 0.1205
R771 O_SENSE_CLK.n80 O_SENSE_CLK.n72 0.1205
R772 O_SENSE_CLK.n81 O_SENSE_CLK.n80 0.1205
R773 O_SENSE_CLK.n82 O_SENSE_CLK.n81 0.1205
R774 O_SENSE_CLK.n83 O_SENSE_CLK.n82 0.1205
R775 O_SENSE_CLK.n84 O_SENSE_CLK.n83 0.1205
R776 O_SENSE_CLK.n85 O_SENSE_CLK.n84 0.1205
R777 O_SENSE_CLK.n86 O_SENSE_CLK.n85 0.1205
R778 O_SENSE_CLK.n87 O_SENSE_CLK.n86 0.1205
R779 O_SENSE_CLK.n59 O_SENSE_CLK.n56 0.114816
R780 O_SENSE_CLK.n41 O_SENSE_CLK.n35 0.1085
R781 O_SENSE_CLK.n53 O_SENSE_CLK.n52 0.1085
R782 O_SENSE_CLK.n33 O_SENSE_CLK.n32 0.0785
R783 O_SENSE_CLK.n70 O_SENSE_CLK.n69 0.0785
R784 O_SENSE_CLK.n63 O_SENSE_CLK.n56 0.0241842
R785 E_SENSE_CLK.n58 E_SENSE_CLK.t4 139.702
R786 E_SENSE_CLK.n56 E_SENSE_CLK.t0 135.246
R787 E_SENSE_CLK.n61 E_SENSE_CLK.t1 135.246
R788 E_SENSE_CLK.n60 E_SENSE_CLK.t2 135.246
R789 E_SENSE_CLK.n59 E_SENSE_CLK.t3 135.246
R790 E_SENSE_CLK.t14 E_SENSE_CLK.n80 127.788
R791 E_SENSE_CLK.t19 E_SENSE_CLK.n42 127.788
R792 E_SENSE_CLK.t31 E_SENSE_CLK.n15 127.788
R793 E_SENSE_CLK.t26 E_SENSE_CLK.n35 127.776
R794 E_SENSE_CLK.t5 E_SENSE_CLK.n72 127.668
R795 E_SENSE_CLK.t6 E_SENSE_CLK.n95 127.668
R796 E_SENSE_CLK.n94 E_SENSE_CLK.t7 127.668
R797 E_SENSE_CLK.n93 E_SENSE_CLK.t8 127.668
R798 E_SENSE_CLK.t9 E_SENSE_CLK.n75 127.668
R799 E_SENSE_CLK.t10 E_SENSE_CLK.n87 127.668
R800 E_SENSE_CLK.n86 E_SENSE_CLK.t11 127.668
R801 E_SENSE_CLK.n85 E_SENSE_CLK.t12 127.668
R802 E_SENSE_CLK.t13 E_SENSE_CLK.n80 127.668
R803 E_SENSE_CLK.t24 E_SENSE_CLK.n49 127.668
R804 E_SENSE_CLK.t25 E_SENSE_CLK.n35 127.668
R805 E_SENSE_CLK.n42 E_SENSE_CLK.t20 127.668
R806 E_SENSE_CLK.t21 E_SENSE_CLK.n38 127.668
R807 E_SENSE_CLK.n47 E_SENSE_CLK.t22 127.668
R808 E_SENSE_CLK.n48 E_SENSE_CLK.t23 127.668
R809 E_SENSE_CLK.t40 E_SENSE_CLK.n0 127.668
R810 E_SENSE_CLK.n15 E_SENSE_CLK.t32 127.668
R811 E_SENSE_CLK.n14 E_SENSE_CLK.t33 127.668
R812 E_SENSE_CLK.n13 E_SENSE_CLK.t34 127.668
R813 E_SENSE_CLK.n12 E_SENSE_CLK.t35 127.668
R814 E_SENSE_CLK.n11 E_SENSE_CLK.t36 127.668
R815 E_SENSE_CLK.n10 E_SENSE_CLK.t37 127.668
R816 E_SENSE_CLK.n9 E_SENSE_CLK.t38 127.668
R817 E_SENSE_CLK.n8 E_SENSE_CLK.t39 127.668
R818 E_SENSE_CLK.n66 E_SENSE_CLK.t15 113.632
R819 E_SENSE_CLK.n82 E_SENSE_CLK.t14 113.632
R820 E_SENSE_CLK.n29 E_SENSE_CLK.t27 113.632
R821 E_SENSE_CLK.n43 E_SENSE_CLK.t19 113.632
R822 E_SENSE_CLK.n16 E_SENSE_CLK.t31 113.632
R823 E_SENSE_CLK.n52 E_SENSE_CLK.t26 113.629
R824 E_SENSE_CLK.n68 E_SENSE_CLK.t17 109.174
R825 E_SENSE_CLK.n69 E_SENSE_CLK.t18 109.174
R826 E_SENSE_CLK.n67 E_SENSE_CLK.t16 109.174
R827 E_SENSE_CLK.n97 E_SENSE_CLK.t5 109.174
R828 E_SENSE_CLK.n96 E_SENSE_CLK.t6 109.174
R829 E_SENSE_CLK.t7 E_SENSE_CLK.n74 109.174
R830 E_SENSE_CLK.t8 E_SENSE_CLK.n92 109.174
R831 E_SENSE_CLK.n76 E_SENSE_CLK.t9 109.174
R832 E_SENSE_CLK.n88 E_SENSE_CLK.t10 109.174
R833 E_SENSE_CLK.t11 E_SENSE_CLK.n79 109.174
R834 E_SENSE_CLK.t12 E_SENSE_CLK.n84 109.174
R835 E_SENSE_CLK.n81 E_SENSE_CLK.t13 109.174
R836 E_SENSE_CLK.n31 E_SENSE_CLK.t29 109.174
R837 E_SENSE_CLK.n32 E_SENSE_CLK.t30 109.174
R838 E_SENSE_CLK.n30 E_SENSE_CLK.t28 109.174
R839 E_SENSE_CLK.n50 E_SENSE_CLK.t24 109.174
R840 E_SENSE_CLK.n51 E_SENSE_CLK.t25 109.174
R841 E_SENSE_CLK.n44 E_SENSE_CLK.t20 109.174
R842 E_SENSE_CLK.n45 E_SENSE_CLK.t21 109.174
R843 E_SENSE_CLK.t22 E_SENSE_CLK.n46 109.174
R844 E_SENSE_CLK.t23 E_SENSE_CLK.n37 109.174
R845 E_SENSE_CLK.n25 E_SENSE_CLK.t40 109.174
R846 E_SENSE_CLK.n17 E_SENSE_CLK.t32 109.174
R847 E_SENSE_CLK.n18 E_SENSE_CLK.t33 109.174
R848 E_SENSE_CLK.n19 E_SENSE_CLK.t34 109.174
R849 E_SENSE_CLK.n20 E_SENSE_CLK.t35 109.174
R850 E_SENSE_CLK.n21 E_SENSE_CLK.t36 109.174
R851 E_SENSE_CLK.n22 E_SENSE_CLK.t37 109.174
R852 E_SENSE_CLK.n23 E_SENSE_CLK.t38 109.174
R853 E_SENSE_CLK.n24 E_SENSE_CLK.t39 109.174
R854 E_SENSE_CLK.n71 E_SENSE_CLK.n70 24.5548
R855 E_SENSE_CLK.n34 E_SENSE_CLK.n33 24.5548
R856 E_SENSE_CLK.n34 E_SENSE_CLK.n27 20.0548
R857 E_SENSE_CLK.n63 E_SENSE_CLK.n56 18.5723
R858 E_SENSE_CLK.n70 E_SENSE_CLK.n69 18.5179
R859 E_SENSE_CLK.n33 E_SENSE_CLK.n32 18.5179
R860 E_SENSE_CLK.n62 E_SENSE_CLK.n61 18.4942
R861 E_SENSE_CLK.n60 E_SENSE_CLK.n57 18.4942
R862 E_SENSE_CLK.n68 E_SENSE_CLK.n65 18.4942
R863 E_SENSE_CLK.n98 E_SENSE_CLK.n97 18.4942
R864 E_SENSE_CLK.n96 E_SENSE_CLK.n73 18.4942
R865 E_SENSE_CLK.n77 E_SENSE_CLK.n74 18.4942
R866 E_SENSE_CLK.n92 E_SENSE_CLK.n91 18.4942
R867 E_SENSE_CLK.n90 E_SENSE_CLK.n76 18.4942
R868 E_SENSE_CLK.n89 E_SENSE_CLK.n88 18.4942
R869 E_SENSE_CLK.n79 E_SENSE_CLK.n78 18.4942
R870 E_SENSE_CLK.n84 E_SENSE_CLK.n83 18.4942
R871 E_SENSE_CLK.n31 E_SENSE_CLK.n28 18.4942
R872 E_SENSE_CLK.n50 E_SENSE_CLK.n36 18.4942
R873 E_SENSE_CLK.n45 E_SENSE_CLK.n41 18.4942
R874 E_SENSE_CLK.n46 E_SENSE_CLK.n40 18.4942
R875 E_SENSE_CLK.n39 E_SENSE_CLK.n37 18.4942
R876 E_SENSE_CLK.n26 E_SENSE_CLK.n25 18.4942
R877 E_SENSE_CLK.n18 E_SENSE_CLK.n7 18.4942
R878 E_SENSE_CLK.n19 E_SENSE_CLK.n6 18.4942
R879 E_SENSE_CLK.n20 E_SENSE_CLK.n5 18.4942
R880 E_SENSE_CLK.n21 E_SENSE_CLK.n4 18.4942
R881 E_SENSE_CLK.n22 E_SENSE_CLK.n3 18.4942
R882 E_SENSE_CLK.n23 E_SENSE_CLK.n2 18.4942
R883 E_SENSE_CLK.n24 E_SENSE_CLK.n1 18.4942
R884 E_SENSE_CLK.n100 E_SENSE_CLK.n99 15.5548
R885 E_SENSE_CLK.n55 E_SENSE_CLK.n54 15.5548
R886 E_SENSE_CLK.n64 E_SENSE_CLK.n63 14.5766
R887 E_SENSE_CLK E_SENSE_CLK.n100 13.9118
R888 E_SENSE_CLK.n61 E_SENSE_CLK.n56 11.6805
R889 E_SENSE_CLK.n61 E_SENSE_CLK.n60 11.6805
R890 E_SENSE_CLK.n60 E_SENSE_CLK.n59 11.6805
R891 E_SENSE_CLK.n68 E_SENSE_CLK.n67 11.6805
R892 E_SENSE_CLK.n69 E_SENSE_CLK.n68 11.6805
R893 E_SENSE_CLK.n97 E_SENSE_CLK.n96 11.6805
R894 E_SENSE_CLK.n96 E_SENSE_CLK.n74 11.6805
R895 E_SENSE_CLK.n92 E_SENSE_CLK.n74 11.6805
R896 E_SENSE_CLK.n92 E_SENSE_CLK.n76 11.6805
R897 E_SENSE_CLK.n88 E_SENSE_CLK.n76 11.6805
R898 E_SENSE_CLK.n88 E_SENSE_CLK.n79 11.6805
R899 E_SENSE_CLK.n84 E_SENSE_CLK.n79 11.6805
R900 E_SENSE_CLK.n84 E_SENSE_CLK.n81 11.6805
R901 E_SENSE_CLK.n31 E_SENSE_CLK.n30 11.6805
R902 E_SENSE_CLK.n32 E_SENSE_CLK.n31 11.6805
R903 E_SENSE_CLK.n51 E_SENSE_CLK.n50 11.6805
R904 E_SENSE_CLK.n45 E_SENSE_CLK.n44 11.6805
R905 E_SENSE_CLK.n46 E_SENSE_CLK.n45 11.6805
R906 E_SENSE_CLK.n46 E_SENSE_CLK.n37 11.6805
R907 E_SENSE_CLK.n50 E_SENSE_CLK.n37 11.6805
R908 E_SENSE_CLK.n18 E_SENSE_CLK.n17 11.6805
R909 E_SENSE_CLK.n19 E_SENSE_CLK.n18 11.6805
R910 E_SENSE_CLK.n20 E_SENSE_CLK.n19 11.6805
R911 E_SENSE_CLK.n21 E_SENSE_CLK.n20 11.6805
R912 E_SENSE_CLK.n22 E_SENSE_CLK.n21 11.6805
R913 E_SENSE_CLK.n23 E_SENSE_CLK.n22 11.6805
R914 E_SENSE_CLK.n24 E_SENSE_CLK.n23 11.6805
R915 E_SENSE_CLK.n25 E_SENSE_CLK.n24 11.6805
R916 E_SENSE_CLK.n27 E_SENSE_CLK.n0 11.1876
R917 E_SENSE_CLK.n99 E_SENSE_CLK.n72 11.0376
R918 E_SENSE_CLK.n54 E_SENSE_CLK.n35 10.8396
R919 E_SENSE_CLK.n27 E_SENSE_CLK.n26 9.3485
R920 E_SENSE_CLK.n99 E_SENSE_CLK.n98 9.1985
R921 E_SENSE_CLK.n54 E_SENSE_CLK.n53 9.0005
R922 E_SENSE_CLK.n58 E_SENSE_CLK.n57 7.17687
R923 E_SENSE_CLK.n66 E_SENSE_CLK.n65 7.17687
R924 E_SENSE_CLK.n83 E_SENSE_CLK.n82 7.17687
R925 E_SENSE_CLK.n29 E_SENSE_CLK.n28 7.17687
R926 E_SENSE_CLK.n43 E_SENSE_CLK.n41 7.17687
R927 E_SENSE_CLK.n16 E_SENSE_CLK.n7 7.17687
R928 E_SENSE_CLK.n53 E_SENSE_CLK.n52 7.05405
R929 E_SENSE_CLK.n100 E_SENSE_CLK.n71 4.69615
R930 E_SENSE_CLK.n52 E_SENSE_CLK.n51 4.4296
R931 E_SENSE_CLK.n59 E_SENSE_CLK.n58 4.42851
R932 E_SENSE_CLK.n67 E_SENSE_CLK.n66 4.42851
R933 E_SENSE_CLK.n82 E_SENSE_CLK.n81 4.42851
R934 E_SENSE_CLK.n30 E_SENSE_CLK.n29 4.42851
R935 E_SENSE_CLK.n44 E_SENSE_CLK.n43 4.42851
R936 E_SENSE_CLK.n17 E_SENSE_CLK.n16 4.42851
R937 E_SENSE_CLK.n55 E_SENSE_CLK.n34 3.32659
R938 E_SENSE_CLK.n71 E_SENSE_CLK.n64 2.73963
R939 E_SENSE_CLK.n64 E_SENSE_CLK.n55 0.978761
R940 E_SENSE_CLK.n83 E_SENSE_CLK.n78 0.1205
R941 E_SENSE_CLK.n89 E_SENSE_CLK.n78 0.1205
R942 E_SENSE_CLK.n90 E_SENSE_CLK.n89 0.1205
R943 E_SENSE_CLK.n91 E_SENSE_CLK.n90 0.1205
R944 E_SENSE_CLK.n91 E_SENSE_CLK.n77 0.1205
R945 E_SENSE_CLK.n77 E_SENSE_CLK.n73 0.1205
R946 E_SENSE_CLK.n98 E_SENSE_CLK.n73 0.1205
R947 E_SENSE_CLK.n85 E_SENSE_CLK.n80 0.1205
R948 E_SENSE_CLK.n86 E_SENSE_CLK.n85 0.1205
R949 E_SENSE_CLK.n87 E_SENSE_CLK.n86 0.1205
R950 E_SENSE_CLK.n87 E_SENSE_CLK.n75 0.1205
R951 E_SENSE_CLK.n93 E_SENSE_CLK.n75 0.1205
R952 E_SENSE_CLK.n94 E_SENSE_CLK.n93 0.1205
R953 E_SENSE_CLK.n95 E_SENSE_CLK.n94 0.1205
R954 E_SENSE_CLK.n95 E_SENSE_CLK.n72 0.1205
R955 E_SENSE_CLK.n39 E_SENSE_CLK.n36 0.1205
R956 E_SENSE_CLK.n40 E_SENSE_CLK.n39 0.1205
R957 E_SENSE_CLK.n41 E_SENSE_CLK.n40 0.1205
R958 E_SENSE_CLK.n49 E_SENSE_CLK.n48 0.1205
R959 E_SENSE_CLK.n48 E_SENSE_CLK.n47 0.1205
R960 E_SENSE_CLK.n47 E_SENSE_CLK.n38 0.1205
R961 E_SENSE_CLK.n42 E_SENSE_CLK.n38 0.1205
R962 E_SENSE_CLK.n26 E_SENSE_CLK.n1 0.1205
R963 E_SENSE_CLK.n2 E_SENSE_CLK.n1 0.1205
R964 E_SENSE_CLK.n3 E_SENSE_CLK.n2 0.1205
R965 E_SENSE_CLK.n4 E_SENSE_CLK.n3 0.1205
R966 E_SENSE_CLK.n5 E_SENSE_CLK.n4 0.1205
R967 E_SENSE_CLK.n6 E_SENSE_CLK.n5 0.1205
R968 E_SENSE_CLK.n7 E_SENSE_CLK.n6 0.1205
R969 E_SENSE_CLK.n8 E_SENSE_CLK.n0 0.1205
R970 E_SENSE_CLK.n9 E_SENSE_CLK.n8 0.1205
R971 E_SENSE_CLK.n10 E_SENSE_CLK.n9 0.1205
R972 E_SENSE_CLK.n11 E_SENSE_CLK.n10 0.1205
R973 E_SENSE_CLK.n12 E_SENSE_CLK.n11 0.1205
R974 E_SENSE_CLK.n13 E_SENSE_CLK.n12 0.1205
R975 E_SENSE_CLK.n14 E_SENSE_CLK.n13 0.1205
R976 E_SENSE_CLK.n15 E_SENSE_CLK.n14 0.1205
R977 E_SENSE_CLK.n62 E_SENSE_CLK.n57 0.114816
R978 E_SENSE_CLK.n53 E_SENSE_CLK.n36 0.1085
R979 E_SENSE_CLK.n49 E_SENSE_CLK.n35 0.1085
R980 E_SENSE_CLK.n70 E_SENSE_CLK.n65 0.0785
R981 E_SENSE_CLK.n33 E_SENSE_CLK.n28 0.0785
R982 E_SENSE_CLK.n63 E_SENSE_CLK.n62 0.0241842
R983 O_CAPTURE_CLK.n14 O_CAPTURE_CLK.t8 113.632
R984 O_CAPTURE_CLK.n18 O_CAPTURE_CLK.t15 113.632
R985 O_CAPTURE_CLK.n5 O_CAPTURE_CLK.t7 113.632
R986 O_CAPTURE_CLK.n23 O_CAPTURE_CLK.t9 109.174
R987 O_CAPTURE_CLK.n24 O_CAPTURE_CLK.t10 109.174
R988 O_CAPTURE_CLK.n22 O_CAPTURE_CLK.t11 109.174
R989 O_CAPTURE_CLK.n21 O_CAPTURE_CLK.t12 109.174
R990 O_CAPTURE_CLK.n16 O_CAPTURE_CLK.t13 109.174
R991 O_CAPTURE_CLK.n17 O_CAPTURE_CLK.t14 109.174
R992 O_CAPTURE_CLK.n0 O_CAPTURE_CLK.t0 109.174
R993 O_CAPTURE_CLK.n11 O_CAPTURE_CLK.t1 109.174
R994 O_CAPTURE_CLK.n6 O_CAPTURE_CLK.t6 109.174
R995 O_CAPTURE_CLK.n7 O_CAPTURE_CLK.t5 109.174
R996 O_CAPTURE_CLK.n8 O_CAPTURE_CLK.t4 109.174
R997 O_CAPTURE_CLK.n9 O_CAPTURE_CLK.t3 109.174
R998 O_CAPTURE_CLK.n10 O_CAPTURE_CLK.t2 109.174
R999 O_CAPTURE_CLK O_CAPTURE_CLK.n27 54.1377
R1000 O_CAPTURE_CLK.n27 O_CAPTURE_CLK.n13 19.4679
R1001 O_CAPTURE_CLK.n13 O_CAPTURE_CLK.n0 18.5636
R1002 O_CAPTURE_CLK.n25 O_CAPTURE_CLK.n24 18.4942
R1003 O_CAPTURE_CLK.n22 O_CAPTURE_CLK.n15 18.4942
R1004 O_CAPTURE_CLK.n21 O_CAPTURE_CLK.n20 18.4942
R1005 O_CAPTURE_CLK.n19 O_CAPTURE_CLK.n16 18.4942
R1006 O_CAPTURE_CLK.n12 O_CAPTURE_CLK.n11 18.4942
R1007 O_CAPTURE_CLK.n7 O_CAPTURE_CLK.n4 18.4942
R1008 O_CAPTURE_CLK.n8 O_CAPTURE_CLK.n3 18.4942
R1009 O_CAPTURE_CLK.n9 O_CAPTURE_CLK.n2 18.4942
R1010 O_CAPTURE_CLK.n10 O_CAPTURE_CLK.n1 18.4942
R1011 O_CAPTURE_CLK.n27 O_CAPTURE_CLK.n26 14.9288
R1012 O_CAPTURE_CLK.n24 O_CAPTURE_CLK.n23 11.6805
R1013 O_CAPTURE_CLK.n24 O_CAPTURE_CLK.n22 11.6805
R1014 O_CAPTURE_CLK.n22 O_CAPTURE_CLK.n21 11.6805
R1015 O_CAPTURE_CLK.n21 O_CAPTURE_CLK.n16 11.6805
R1016 O_CAPTURE_CLK.n17 O_CAPTURE_CLK.n16 11.6805
R1017 O_CAPTURE_CLK.n11 O_CAPTURE_CLK.n0 11.6805
R1018 O_CAPTURE_CLK.n7 O_CAPTURE_CLK.n6 11.6805
R1019 O_CAPTURE_CLK.n8 O_CAPTURE_CLK.n7 11.6805
R1020 O_CAPTURE_CLK.n9 O_CAPTURE_CLK.n8 11.6805
R1021 O_CAPTURE_CLK.n10 O_CAPTURE_CLK.n9 11.6805
R1022 O_CAPTURE_CLK.n11 O_CAPTURE_CLK.n10 11.6805
R1023 O_CAPTURE_CLK.n19 O_CAPTURE_CLK.n18 7.17687
R1024 O_CAPTURE_CLK.n5 O_CAPTURE_CLK.n4 7.17687
R1025 O_CAPTURE_CLK.n26 O_CAPTURE_CLK.n14 7.10487
R1026 O_CAPTURE_CLK.n23 O_CAPTURE_CLK.n14 4.42851
R1027 O_CAPTURE_CLK.n18 O_CAPTURE_CLK.n17 4.42851
R1028 O_CAPTURE_CLK.n6 O_CAPTURE_CLK.n5 4.42851
R1029 O_CAPTURE_CLK.n20 O_CAPTURE_CLK.n19 0.1205
R1030 O_CAPTURE_CLK.n20 O_CAPTURE_CLK.n15 0.1205
R1031 O_CAPTURE_CLK.n25 O_CAPTURE_CLK.n15 0.1205
R1032 O_CAPTURE_CLK.n4 O_CAPTURE_CLK.n3 0.1205
R1033 O_CAPTURE_CLK.n3 O_CAPTURE_CLK.n2 0.1205
R1034 O_CAPTURE_CLK.n2 O_CAPTURE_CLK.n1 0.1205
R1035 O_CAPTURE_CLK.n12 O_CAPTURE_CLK.n1 0.1205
R1036 O_CAPTURE_CLK.n26 O_CAPTURE_CLK.n25 0.0485
R1037 O_CAPTURE_CLK.n13 O_CAPTURE_CLK.n12 0.0485
R1038 E_CAPTURE_CLK.n5 E_CAPTURE_CLK.t7 113.632
R1039 E_CAPTURE_CLK.n14 E_CAPTURE_CLK.t8 113.632
R1040 E_CAPTURE_CLK.n18 E_CAPTURE_CLK.t15 113.632
R1041 E_CAPTURE_CLK.n0 E_CAPTURE_CLK.t0 109.174
R1042 E_CAPTURE_CLK.n11 E_CAPTURE_CLK.t1 109.174
R1043 E_CAPTURE_CLK.n6 E_CAPTURE_CLK.t6 109.174
R1044 E_CAPTURE_CLK.n7 E_CAPTURE_CLK.t5 109.174
R1045 E_CAPTURE_CLK.n8 E_CAPTURE_CLK.t4 109.174
R1046 E_CAPTURE_CLK.n9 E_CAPTURE_CLK.t3 109.174
R1047 E_CAPTURE_CLK.n10 E_CAPTURE_CLK.t2 109.174
R1048 E_CAPTURE_CLK.n23 E_CAPTURE_CLK.t9 109.174
R1049 E_CAPTURE_CLK.n24 E_CAPTURE_CLK.t10 109.174
R1050 E_CAPTURE_CLK.n22 E_CAPTURE_CLK.t11 109.174
R1051 E_CAPTURE_CLK.n21 E_CAPTURE_CLK.t12 109.174
R1052 E_CAPTURE_CLK.n16 E_CAPTURE_CLK.t13 109.174
R1053 E_CAPTURE_CLK.n17 E_CAPTURE_CLK.t14 109.174
R1054 E_CAPTURE_CLK E_CAPTURE_CLK.n27 56.6654
R1055 E_CAPTURE_CLK.n13 E_CAPTURE_CLK.n0 18.5636
R1056 E_CAPTURE_CLK.n12 E_CAPTURE_CLK.n11 18.4942
R1057 E_CAPTURE_CLK.n7 E_CAPTURE_CLK.n4 18.4942
R1058 E_CAPTURE_CLK.n8 E_CAPTURE_CLK.n3 18.4942
R1059 E_CAPTURE_CLK.n9 E_CAPTURE_CLK.n2 18.4942
R1060 E_CAPTURE_CLK.n10 E_CAPTURE_CLK.n1 18.4942
R1061 E_CAPTURE_CLK.n25 E_CAPTURE_CLK.n24 18.4942
R1062 E_CAPTURE_CLK.n22 E_CAPTURE_CLK.n15 18.4942
R1063 E_CAPTURE_CLK.n21 E_CAPTURE_CLK.n20 18.4942
R1064 E_CAPTURE_CLK.n19 E_CAPTURE_CLK.n16 18.4942
R1065 E_CAPTURE_CLK.n27 E_CAPTURE_CLK.n13 18.4114
R1066 E_CAPTURE_CLK.n27 E_CAPTURE_CLK.n26 13.5592
R1067 E_CAPTURE_CLK.n11 E_CAPTURE_CLK.n0 11.6805
R1068 E_CAPTURE_CLK.n7 E_CAPTURE_CLK.n6 11.6805
R1069 E_CAPTURE_CLK.n8 E_CAPTURE_CLK.n7 11.6805
R1070 E_CAPTURE_CLK.n9 E_CAPTURE_CLK.n8 11.6805
R1071 E_CAPTURE_CLK.n10 E_CAPTURE_CLK.n9 11.6805
R1072 E_CAPTURE_CLK.n11 E_CAPTURE_CLK.n10 11.6805
R1073 E_CAPTURE_CLK.n24 E_CAPTURE_CLK.n23 11.6805
R1074 E_CAPTURE_CLK.n24 E_CAPTURE_CLK.n22 11.6805
R1075 E_CAPTURE_CLK.n22 E_CAPTURE_CLK.n21 11.6805
R1076 E_CAPTURE_CLK.n21 E_CAPTURE_CLK.n16 11.6805
R1077 E_CAPTURE_CLK.n17 E_CAPTURE_CLK.n16 11.6805
R1078 E_CAPTURE_CLK.n5 E_CAPTURE_CLK.n4 7.17687
R1079 E_CAPTURE_CLK.n19 E_CAPTURE_CLK.n18 7.17687
R1080 E_CAPTURE_CLK.n26 E_CAPTURE_CLK.n14 7.10487
R1081 E_CAPTURE_CLK.n6 E_CAPTURE_CLK.n5 4.42851
R1082 E_CAPTURE_CLK.n23 E_CAPTURE_CLK.n14 4.42851
R1083 E_CAPTURE_CLK.n18 E_CAPTURE_CLK.n17 4.42851
R1084 E_CAPTURE_CLK.n4 E_CAPTURE_CLK.n3 0.1205
R1085 E_CAPTURE_CLK.n3 E_CAPTURE_CLK.n2 0.1205
R1086 E_CAPTURE_CLK.n2 E_CAPTURE_CLK.n1 0.1205
R1087 E_CAPTURE_CLK.n12 E_CAPTURE_CLK.n1 0.1205
R1088 E_CAPTURE_CLK.n20 E_CAPTURE_CLK.n19 0.1205
R1089 E_CAPTURE_CLK.n20 E_CAPTURE_CLK.n15 0.1205
R1090 E_CAPTURE_CLK.n25 E_CAPTURE_CLK.n15 0.1205
R1091 E_CAPTURE_CLK.n13 E_CAPTURE_CLK.n12 0.0485
R1092 E_CAPTURE_CLK.n26 E_CAPTURE_CLK.n25 0.0485
R1093 FE_O_N.n16 FE_O_N.t10 113.632
R1094 FE_O_N.n13 FE_O_N.t7 113.632
R1095 FE_O_N.n6 FE_O_N.t11 113.632
R1096 FE_O_N.n2 FE_O_N.t18 113.632
R1097 FE_O_N.n14 FE_O_N.t8 109.174
R1098 FE_O_N.n15 FE_O_N.t9 109.174
R1099 FE_O_N.n7 FE_O_N.t12 109.174
R1100 FE_O_N.n8 FE_O_N.t13 109.174
R1101 FE_O_N.n9 FE_O_N.t14 109.174
R1102 FE_O_N.n10 FE_O_N.t15 109.174
R1103 FE_O_N.n4 FE_O_N.t16 109.174
R1104 FE_O_N.n3 FE_O_N.t17 109.174
R1105 FE_O_N.n25 FE_O_N.n18 72.2821
R1106 FE_O_N.n8 FE_O_N.n5 18.4942
R1107 FE_O_N.n9 FE_O_N.n0 18.4942
R1108 FE_O_N.n11 FE_O_N.n10 18.4942
R1109 FE_O_N.n4 FE_O_N.n1 18.4942
R1110 FE_O_N.n18 FE_O_N.n12 14.8701
R1111 FE_O_N.n15 FE_O_N.n14 11.6805
R1112 FE_O_N.n8 FE_O_N.n7 11.6805
R1113 FE_O_N.n9 FE_O_N.n8 11.6805
R1114 FE_O_N.n10 FE_O_N.n9 11.6805
R1115 FE_O_N.n10 FE_O_N.n4 11.6805
R1116 FE_O_N.n4 FE_O_N.n3 11.6805
R1117 FE_O_N.n24 FE_O_N.n21 10.957
R1118 FE_O_N.n24 FE_O_N.n23 10.5657
R1119 FE_O_N.n18 FE_O_N.n17 9.0005
R1120 FE_O_N.n25 FE_O_N.n24 8.57007
R1121 FE_O_N.n6 FE_O_N.n5 7.17687
R1122 FE_O_N.n2 FE_O_N.n1 7.17687
R1123 FE_O_N.n17 FE_O_N.n13 7.10487
R1124 FE_O_N.n17 FE_O_N.n16 7.10487
R1125 FE_O_N.n20 FE_O_N.t3 5.7796
R1126 FE_O_N.n23 FE_O_N.t2 5.71396
R1127 FE_O_N.n21 FE_O_N.t6 5.68486
R1128 FE_O_N.n20 FE_O_N.n19 5.38537
R1129 FE_O_N.n23 FE_O_N.n22 5.34435
R1130 FE_O_N.n14 FE_O_N.n13 4.42851
R1131 FE_O_N.n16 FE_O_N.n15 4.42851
R1132 FE_O_N.n7 FE_O_N.n6 4.42851
R1133 FE_O_N.n3 FE_O_N.n2 4.42851
R1134 FE_O_N.n22 FE_O_N.t1 0.228
R1135 FE_O_N.n22 FE_O_N.t0 0.228
R1136 FE_O_N.n19 FE_O_N.t5 0.20525
R1137 FE_O_N.n19 FE_O_N.t4 0.20525
R1138 FE_O_N.n5 FE_O_N.n0 0.1205
R1139 FE_O_N.n11 FE_O_N.n1 0.1205
R1140 FE_O_N.n21 FE_O_N.n20 0.0952368
R1141 FE_O_N.n12 FE_O_N.n0 0.0485
R1142 FE_O_N.n12 FE_O_N.n11 0.0485
R1143 FE_O_N FE_O_N.n25 0.0205
R1144 FE_O_P.n16 FE_O_P.t10 113.632
R1145 FE_O_P.n13 FE_O_P.t7 113.632
R1146 FE_O_P.n6 FE_O_P.t11 113.632
R1147 FE_O_P.n2 FE_O_P.t18 113.632
R1148 FE_O_P.n14 FE_O_P.t8 109.174
R1149 FE_O_P.n15 FE_O_P.t9 109.174
R1150 FE_O_P.n7 FE_O_P.t12 109.174
R1151 FE_O_P.n8 FE_O_P.t13 109.174
R1152 FE_O_P.n9 FE_O_P.t14 109.174
R1153 FE_O_P.n10 FE_O_P.t15 109.174
R1154 FE_O_P.n4 FE_O_P.t16 109.174
R1155 FE_O_P.n3 FE_O_P.t17 109.174
R1156 FE_O_P FE_O_P.n18 74.3873
R1157 FE_O_P.n8 FE_O_P.n5 18.4942
R1158 FE_O_P.n9 FE_O_P.n0 18.4942
R1159 FE_O_P.n11 FE_O_P.n10 18.4942
R1160 FE_O_P.n4 FE_O_P.n1 18.4942
R1161 FE_O_P.n18 FE_O_P.n12 14.8701
R1162 FE_O_P.n15 FE_O_P.n14 11.6805
R1163 FE_O_P.n8 FE_O_P.n7 11.6805
R1164 FE_O_P.n9 FE_O_P.n8 11.6805
R1165 FE_O_P.n10 FE_O_P.n9 11.6805
R1166 FE_O_P.n10 FE_O_P.n4 11.6805
R1167 FE_O_P.n4 FE_O_P.n3 11.6805
R1168 FE_O_P.n24 FE_O_P.n20 11.0353
R1169 FE_O_P.n24 FE_O_P.n23 10.4875
R1170 FE_O_P.n18 FE_O_P.n17 9.0005
R1171 FE_O_P FE_O_P.n24 8.47267
R1172 FE_O_P.n6 FE_O_P.n5 7.17687
R1173 FE_O_P.n2 FE_O_P.n1 7.17687
R1174 FE_O_P.n17 FE_O_P.n13 7.10487
R1175 FE_O_P.n17 FE_O_P.n16 7.10487
R1176 FE_O_P.n22 FE_O_P.t5 5.7796
R1177 FE_O_P.n20 FE_O_P.t1 5.71396
R1178 FE_O_P.n23 FE_O_P.t4 5.68486
R1179 FE_O_P.n22 FE_O_P.n21 5.38537
R1180 FE_O_P.n20 FE_O_P.n19 5.34435
R1181 FE_O_P.n14 FE_O_P.n13 4.42851
R1182 FE_O_P.n16 FE_O_P.n15 4.42851
R1183 FE_O_P.n7 FE_O_P.n6 4.42851
R1184 FE_O_P.n3 FE_O_P.n2 4.42851
R1185 FE_O_P.n19 FE_O_P.t0 0.228
R1186 FE_O_P.n19 FE_O_P.t2 0.228
R1187 FE_O_P.n21 FE_O_P.t3 0.20525
R1188 FE_O_P.n21 FE_O_P.t6 0.20525
R1189 FE_O_P.n5 FE_O_P.n0 0.1205
R1190 FE_O_P.n11 FE_O_P.n1 0.1205
R1191 FE_O_P.n23 FE_O_P.n22 0.0952368
R1192 FE_O_P.n12 FE_O_P.n0 0.0485
R1193 FE_O_P.n12 FE_O_P.n11 0.0485
R1194 FE_E_P.n16 FE_E_P.t10 113.632
R1195 FE_E_P.n13 FE_E_P.t7 113.632
R1196 FE_E_P.n6 FE_E_P.t11 113.632
R1197 FE_E_P.n2 FE_E_P.t18 113.632
R1198 FE_E_P.n14 FE_E_P.t8 109.174
R1199 FE_E_P.n15 FE_E_P.t9 109.174
R1200 FE_E_P.n7 FE_E_P.t12 109.174
R1201 FE_E_P.n8 FE_E_P.t13 109.174
R1202 FE_E_P.n9 FE_E_P.t14 109.174
R1203 FE_E_P.n10 FE_E_P.t15 109.174
R1204 FE_E_P.n4 FE_E_P.t16 109.174
R1205 FE_E_P.n3 FE_E_P.t17 109.174
R1206 FE_E_P FE_E_P.n18 80.531
R1207 FE_E_P.n8 FE_E_P.n5 18.4942
R1208 FE_E_P.n9 FE_E_P.n0 18.4942
R1209 FE_E_P.n11 FE_E_P.n10 18.4942
R1210 FE_E_P.n4 FE_E_P.n1 18.4942
R1211 FE_E_P.n18 FE_E_P.n12 14.8701
R1212 FE_E_P.n15 FE_E_P.n14 11.6805
R1213 FE_E_P.n8 FE_E_P.n7 11.6805
R1214 FE_E_P.n9 FE_E_P.n8 11.6805
R1215 FE_E_P.n10 FE_E_P.n9 11.6805
R1216 FE_E_P.n10 FE_E_P.n4 11.6805
R1217 FE_E_P.n4 FE_E_P.n3 11.6805
R1218 FE_E_P.n24 FE_E_P.n21 10.957
R1219 FE_E_P.n24 FE_E_P.n23 10.5657
R1220 FE_E_P.n18 FE_E_P.n17 9.0005
R1221 FE_E_P FE_E_P.n24 8.59007
R1222 FE_E_P.n6 FE_E_P.n5 7.17687
R1223 FE_E_P.n2 FE_E_P.n1 7.17687
R1224 FE_E_P.n17 FE_E_P.n13 7.10487
R1225 FE_E_P.n17 FE_E_P.n16 7.10487
R1226 FE_E_P.n20 FE_E_P.t4 5.7796
R1227 FE_E_P.n23 FE_E_P.t1 5.71396
R1228 FE_E_P.n21 FE_E_P.t0 5.68486
R1229 FE_E_P.n20 FE_E_P.n19 5.38537
R1230 FE_E_P.n23 FE_E_P.n22 5.34435
R1231 FE_E_P.n14 FE_E_P.n13 4.42851
R1232 FE_E_P.n16 FE_E_P.n15 4.42851
R1233 FE_E_P.n7 FE_E_P.n6 4.42851
R1234 FE_E_P.n3 FE_E_P.n2 4.42851
R1235 FE_E_P.n22 FE_E_P.t6 0.228
R1236 FE_E_P.n22 FE_E_P.t5 0.228
R1237 FE_E_P.n19 FE_E_P.t3 0.20525
R1238 FE_E_P.n19 FE_E_P.t2 0.20525
R1239 FE_E_P.n5 FE_E_P.n0 0.1205
R1240 FE_E_P.n11 FE_E_P.n1 0.1205
R1241 FE_E_P.n21 FE_E_P.n20 0.0952368
R1242 FE_E_P.n12 FE_E_P.n0 0.0485
R1243 FE_E_P.n12 FE_E_P.n11 0.0485
R1244 FE_E_N.n16 FE_E_N.t10 113.632
R1245 FE_E_N.n13 FE_E_N.t7 113.632
R1246 FE_E_N.n6 FE_E_N.t11 113.632
R1247 FE_E_N.n2 FE_E_N.t18 113.632
R1248 FE_E_N.n14 FE_E_N.t8 109.174
R1249 FE_E_N.n15 FE_E_N.t9 109.174
R1250 FE_E_N.n7 FE_E_N.t12 109.174
R1251 FE_E_N.n8 FE_E_N.t13 109.174
R1252 FE_E_N.n9 FE_E_N.t14 109.174
R1253 FE_E_N.n10 FE_E_N.t15 109.174
R1254 FE_E_N.n4 FE_E_N.t16 109.174
R1255 FE_E_N.n3 FE_E_N.t17 109.174
R1256 FE_E_N.n25 FE_E_N.n18 77.8095
R1257 FE_E_N.n8 FE_E_N.n5 18.4942
R1258 FE_E_N.n9 FE_E_N.n0 18.4942
R1259 FE_E_N.n11 FE_E_N.n10 18.4942
R1260 FE_E_N.n4 FE_E_N.n1 18.4942
R1261 FE_E_N.n18 FE_E_N.n12 14.8701
R1262 FE_E_N.n15 FE_E_N.n14 11.6805
R1263 FE_E_N.n8 FE_E_N.n7 11.6805
R1264 FE_E_N.n9 FE_E_N.n8 11.6805
R1265 FE_E_N.n10 FE_E_N.n9 11.6805
R1266 FE_E_N.n10 FE_E_N.n4 11.6805
R1267 FE_E_N.n4 FE_E_N.n3 11.6805
R1268 FE_E_N.n24 FE_E_N.n20 11.0353
R1269 FE_E_N.n24 FE_E_N.n23 10.4875
R1270 FE_E_N.n18 FE_E_N.n17 9.0005
R1271 FE_E_N.n25 FE_E_N.n24 8.45267
R1272 FE_E_N.n6 FE_E_N.n5 7.17687
R1273 FE_E_N.n2 FE_E_N.n1 7.17687
R1274 FE_E_N.n17 FE_E_N.n13 7.10487
R1275 FE_E_N.n17 FE_E_N.n16 7.10487
R1276 FE_E_N.n22 FE_E_N.t5 5.7796
R1277 FE_E_N.n20 FE_E_N.t6 5.71396
R1278 FE_E_N.n23 FE_E_N.t0 5.68486
R1279 FE_E_N.n22 FE_E_N.n21 5.38537
R1280 FE_E_N.n20 FE_E_N.n19 5.34435
R1281 FE_E_N.n14 FE_E_N.n13 4.42851
R1282 FE_E_N.n16 FE_E_N.n15 4.42851
R1283 FE_E_N.n7 FE_E_N.n6 4.42851
R1284 FE_E_N.n3 FE_E_N.n2 4.42851
R1285 FE_E_N.n19 FE_E_N.t3 0.228
R1286 FE_E_N.n19 FE_E_N.t2 0.228
R1287 FE_E_N.n21 FE_E_N.t4 0.20525
R1288 FE_E_N.n21 FE_E_N.t1 0.20525
R1289 FE_E_N.n5 FE_E_N.n0 0.1205
R1290 FE_E_N.n11 FE_E_N.n1 0.1205
R1291 FE_E_N.n23 FE_E_N.n22 0.0952368
R1292 FE_E_N.n12 FE_E_N.n0 0.0485
R1293 FE_E_N.n12 FE_E_N.n11 0.0485
R1294 FE_E_N FE_E_N.n25 0.0205
R1295 ODD_Q.n5 ODD_Q.n2 12.9918
R1296 ODD_Q ODD_Q.n5 10.5466
R1297 ODD_Q.n1 ODD_Q.t1 5.73764
R1298 ODD_Q.n2 ODD_Q.t5 5.6429
R1299 ODD_Q.n4 ODD_Q.t2 5.63749
R1300 ODD_Q.n4 ODD_Q.n3 5.52748
R1301 ODD_Q.n1 ODD_Q.n0 5.32067
R1302 ODD_Q.n5 ODD_Q.n4 4.61789
R1303 ODD_Q.n0 ODD_Q.t6 0.228
R1304 ODD_Q.n0 ODD_Q.t4 0.228
R1305 ODD_Q.n3 ODD_Q.t0 0.20525
R1306 ODD_Q.n3 ODD_Q.t3 0.20525
R1307 ODD_Q.n2 ODD_Q.n1 0.0952368
R1308 ODD_QB ODD_QB.n5 21.5031
R1309 ODD_QB.n5 ODD_QB.n2 12.7179
R1310 ODD_QB.n1 ODD_QB.t4 5.73764
R1311 ODD_QB.n2 ODD_QB.t1 5.6429
R1312 ODD_QB.n4 ODD_QB.t0 5.63749
R1313 ODD_QB.n4 ODD_QB.n3 5.52748
R1314 ODD_QB.n1 ODD_QB.n0 5.32067
R1315 ODD_QB.n5 ODD_QB.n4 4.8918
R1316 ODD_QB.n0 ODD_QB.t6 0.228
R1317 ODD_QB.n0 ODD_QB.t3 0.228
R1318 ODD_QB.n3 ODD_QB.t5 0.20525
R1319 ODD_QB.n3 ODD_QB.t2 0.20525
R1320 ODD_QB.n2 ODD_QB.n1 0.0952368
R1321 EVEN_QB EVEN_QB.n5 20.9553
R1322 EVEN_QB.n5 EVEN_QB.n2 13.1092
R1323 EVEN_QB.n1 EVEN_QB.t3 5.73764
R1324 EVEN_QB.n2 EVEN_QB.t1 5.6429
R1325 EVEN_QB.n4 EVEN_QB.t0 5.63749
R1326 EVEN_QB.n4 EVEN_QB.n3 5.52748
R1327 EVEN_QB.n1 EVEN_QB.n0 5.32067
R1328 EVEN_QB.n5 EVEN_QB.n4 4.5005
R1329 EVEN_QB.n0 EVEN_QB.t2 0.228
R1330 EVEN_QB.n0 EVEN_QB.t4 0.228
R1331 EVEN_QB.n3 EVEN_QB.t5 0.20525
R1332 EVEN_QB.n3 EVEN_QB.t6 0.20525
R1333 EVEN_QB.n2 EVEN_QB.n1 0.0952368
R1334 EVEN_Q.n5 EVEN_Q.n2 13.1092
R1335 EVEN_Q EVEN_Q.n5 11.0553
R1336 EVEN_Q.n1 EVEN_Q.t6 5.73764
R1337 EVEN_Q.n2 EVEN_Q.t3 5.6429
R1338 EVEN_Q.n4 EVEN_Q.t2 5.63749
R1339 EVEN_Q.n4 EVEN_Q.n3 5.52748
R1340 EVEN_Q.n1 EVEN_Q.n0 5.32067
R1341 EVEN_Q.n5 EVEN_Q.n4 4.5005
R1342 EVEN_Q.n0 EVEN_Q.t4 0.228
R1343 EVEN_Q.n0 EVEN_Q.t1 0.228
R1344 EVEN_Q.n3 EVEN_Q.t0 0.20525
R1345 EVEN_Q.n3 EVEN_Q.t5 0.20525
R1346 EVEN_Q.n2 EVEN_Q.n1 0.0952368
R1347 O_CAPTURE_CLKB.n17 O_CAPTURE_CLKB.t0 113.632
R1348 O_CAPTURE_CLKB.n5 O_CAPTURE_CLKB.t8 113.632
R1349 O_CAPTURE_CLKB.n26 O_CAPTURE_CLKB.t7 109.174
R1350 O_CAPTURE_CLKB.n25 O_CAPTURE_CLKB.t6 109.174
R1351 O_CAPTURE_CLKB.n24 O_CAPTURE_CLKB.t5 109.174
R1352 O_CAPTURE_CLKB.n15 O_CAPTURE_CLKB.t4 109.174
R1353 O_CAPTURE_CLKB.n20 O_CAPTURE_CLKB.t3 109.174
R1354 O_CAPTURE_CLKB.n19 O_CAPTURE_CLKB.t2 109.174
R1355 O_CAPTURE_CLKB.n18 O_CAPTURE_CLKB.t1 109.174
R1356 O_CAPTURE_CLKB.n6 O_CAPTURE_CLKB.t9 109.174
R1357 O_CAPTURE_CLKB.n7 O_CAPTURE_CLKB.t10 109.174
R1358 O_CAPTURE_CLKB.n8 O_CAPTURE_CLKB.t11 109.174
R1359 O_CAPTURE_CLKB.n9 O_CAPTURE_CLKB.t12 109.174
R1360 O_CAPTURE_CLKB.n10 O_CAPTURE_CLKB.t13 109.174
R1361 O_CAPTURE_CLKB.n11 O_CAPTURE_CLKB.t14 109.174
R1362 O_CAPTURE_CLKB.n12 O_CAPTURE_CLKB.t15 109.174
R1363 O_CAPTURE_CLKB O_CAPTURE_CLKB.n28 71.3295
R1364 O_CAPTURE_CLKB.n27 O_CAPTURE_CLKB.n26 18.4942
R1365 O_CAPTURE_CLKB.n25 O_CAPTURE_CLKB.n14 18.4942
R1366 O_CAPTURE_CLKB.n24 O_CAPTURE_CLKB.n23 18.4942
R1367 O_CAPTURE_CLKB.n22 O_CAPTURE_CLKB.n15 18.4942
R1368 O_CAPTURE_CLKB.n21 O_CAPTURE_CLKB.n20 18.4942
R1369 O_CAPTURE_CLKB.n19 O_CAPTURE_CLKB.n16 18.4942
R1370 O_CAPTURE_CLKB.n7 O_CAPTURE_CLKB.n4 18.4942
R1371 O_CAPTURE_CLKB.n8 O_CAPTURE_CLKB.n3 18.4942
R1372 O_CAPTURE_CLKB.n9 O_CAPTURE_CLKB.n2 18.4942
R1373 O_CAPTURE_CLKB.n10 O_CAPTURE_CLKB.n1 18.4942
R1374 O_CAPTURE_CLKB.n11 O_CAPTURE_CLKB.n0 18.4942
R1375 O_CAPTURE_CLKB.n13 O_CAPTURE_CLKB.n12 18.4942
R1376 O_CAPTURE_CLKB.n28 O_CAPTURE_CLKB.n13 14.2555
R1377 O_CAPTURE_CLKB.n26 O_CAPTURE_CLKB.n25 11.6805
R1378 O_CAPTURE_CLKB.n25 O_CAPTURE_CLKB.n24 11.6805
R1379 O_CAPTURE_CLKB.n24 O_CAPTURE_CLKB.n15 11.6805
R1380 O_CAPTURE_CLKB.n20 O_CAPTURE_CLKB.n15 11.6805
R1381 O_CAPTURE_CLKB.n20 O_CAPTURE_CLKB.n19 11.6805
R1382 O_CAPTURE_CLKB.n19 O_CAPTURE_CLKB.n18 11.6805
R1383 O_CAPTURE_CLKB.n7 O_CAPTURE_CLKB.n6 11.6805
R1384 O_CAPTURE_CLKB.n8 O_CAPTURE_CLKB.n7 11.6805
R1385 O_CAPTURE_CLKB.n9 O_CAPTURE_CLKB.n8 11.6805
R1386 O_CAPTURE_CLKB.n10 O_CAPTURE_CLKB.n9 11.6805
R1387 O_CAPTURE_CLKB.n11 O_CAPTURE_CLKB.n10 11.6805
R1388 O_CAPTURE_CLKB.n12 O_CAPTURE_CLKB.n11 11.6805
R1389 O_CAPTURE_CLKB.n28 O_CAPTURE_CLKB.n27 9.1685
R1390 O_CAPTURE_CLKB.n17 O_CAPTURE_CLKB.n16 7.17687
R1391 O_CAPTURE_CLKB.n5 O_CAPTURE_CLKB.n4 7.17687
R1392 O_CAPTURE_CLKB.n18 O_CAPTURE_CLKB.n17 4.42851
R1393 O_CAPTURE_CLKB.n6 O_CAPTURE_CLKB.n5 4.42851
R1394 O_CAPTURE_CLKB.n27 O_CAPTURE_CLKB.n14 0.1205
R1395 O_CAPTURE_CLKB.n23 O_CAPTURE_CLKB.n14 0.1205
R1396 O_CAPTURE_CLKB.n23 O_CAPTURE_CLKB.n22 0.1205
R1397 O_CAPTURE_CLKB.n22 O_CAPTURE_CLKB.n21 0.1205
R1398 O_CAPTURE_CLKB.n21 O_CAPTURE_CLKB.n16 0.1205
R1399 O_CAPTURE_CLKB.n13 O_CAPTURE_CLKB.n0 0.1205
R1400 O_CAPTURE_CLKB.n1 O_CAPTURE_CLKB.n0 0.1205
R1401 O_CAPTURE_CLKB.n2 O_CAPTURE_CLKB.n1 0.1205
R1402 O_CAPTURE_CLKB.n3 O_CAPTURE_CLKB.n2 0.1205
R1403 O_CAPTURE_CLKB.n4 O_CAPTURE_CLKB.n3 0.1205
R1404 E_CAPTURE_CLKB.n17 E_CAPTURE_CLKB.t0 113.632
R1405 E_CAPTURE_CLKB.n5 E_CAPTURE_CLKB.t8 113.632
R1406 E_CAPTURE_CLKB.n26 E_CAPTURE_CLKB.t7 109.174
R1407 E_CAPTURE_CLKB.n25 E_CAPTURE_CLKB.t6 109.174
R1408 E_CAPTURE_CLKB.n24 E_CAPTURE_CLKB.t5 109.174
R1409 E_CAPTURE_CLKB.n15 E_CAPTURE_CLKB.t4 109.174
R1410 E_CAPTURE_CLKB.n20 E_CAPTURE_CLKB.t3 109.174
R1411 E_CAPTURE_CLKB.n19 E_CAPTURE_CLKB.t2 109.174
R1412 E_CAPTURE_CLKB.n18 E_CAPTURE_CLKB.t1 109.174
R1413 E_CAPTURE_CLKB.n6 E_CAPTURE_CLKB.t9 109.174
R1414 E_CAPTURE_CLKB.n7 E_CAPTURE_CLKB.t10 109.174
R1415 E_CAPTURE_CLKB.n8 E_CAPTURE_CLKB.t11 109.174
R1416 E_CAPTURE_CLKB.n9 E_CAPTURE_CLKB.t12 109.174
R1417 E_CAPTURE_CLKB.n10 E_CAPTURE_CLKB.t13 109.174
R1418 E_CAPTURE_CLKB.n11 E_CAPTURE_CLKB.t14 109.174
R1419 E_CAPTURE_CLKB.n12 E_CAPTURE_CLKB.t15 109.174
R1420 E_CAPTURE_CLKB E_CAPTURE_CLKB.n28 72.4605
R1421 E_CAPTURE_CLKB.n27 E_CAPTURE_CLKB.n26 18.4942
R1422 E_CAPTURE_CLKB.n25 E_CAPTURE_CLKB.n14 18.4942
R1423 E_CAPTURE_CLKB.n24 E_CAPTURE_CLKB.n23 18.4942
R1424 E_CAPTURE_CLKB.n22 E_CAPTURE_CLKB.n15 18.4942
R1425 E_CAPTURE_CLKB.n21 E_CAPTURE_CLKB.n20 18.4942
R1426 E_CAPTURE_CLKB.n19 E_CAPTURE_CLKB.n16 18.4942
R1427 E_CAPTURE_CLKB.n7 E_CAPTURE_CLKB.n4 18.4942
R1428 E_CAPTURE_CLKB.n8 E_CAPTURE_CLKB.n3 18.4942
R1429 E_CAPTURE_CLKB.n9 E_CAPTURE_CLKB.n2 18.4942
R1430 E_CAPTURE_CLKB.n10 E_CAPTURE_CLKB.n1 18.4942
R1431 E_CAPTURE_CLKB.n11 E_CAPTURE_CLKB.n0 18.4942
R1432 E_CAPTURE_CLKB.n13 E_CAPTURE_CLKB.n12 18.4942
R1433 E_CAPTURE_CLKB.n28 E_CAPTURE_CLKB.n13 14.2555
R1434 E_CAPTURE_CLKB.n26 E_CAPTURE_CLKB.n25 11.6805
R1435 E_CAPTURE_CLKB.n25 E_CAPTURE_CLKB.n24 11.6805
R1436 E_CAPTURE_CLKB.n24 E_CAPTURE_CLKB.n15 11.6805
R1437 E_CAPTURE_CLKB.n20 E_CAPTURE_CLKB.n15 11.6805
R1438 E_CAPTURE_CLKB.n20 E_CAPTURE_CLKB.n19 11.6805
R1439 E_CAPTURE_CLKB.n19 E_CAPTURE_CLKB.n18 11.6805
R1440 E_CAPTURE_CLKB.n7 E_CAPTURE_CLKB.n6 11.6805
R1441 E_CAPTURE_CLKB.n8 E_CAPTURE_CLKB.n7 11.6805
R1442 E_CAPTURE_CLKB.n9 E_CAPTURE_CLKB.n8 11.6805
R1443 E_CAPTURE_CLKB.n10 E_CAPTURE_CLKB.n9 11.6805
R1444 E_CAPTURE_CLKB.n11 E_CAPTURE_CLKB.n10 11.6805
R1445 E_CAPTURE_CLKB.n12 E_CAPTURE_CLKB.n11 11.6805
R1446 E_CAPTURE_CLKB.n28 E_CAPTURE_CLKB.n27 9.1685
R1447 E_CAPTURE_CLKB.n17 E_CAPTURE_CLKB.n16 7.17687
R1448 E_CAPTURE_CLKB.n5 E_CAPTURE_CLKB.n4 7.17687
R1449 E_CAPTURE_CLKB.n18 E_CAPTURE_CLKB.n17 4.42851
R1450 E_CAPTURE_CLKB.n6 E_CAPTURE_CLKB.n5 4.42851
R1451 E_CAPTURE_CLKB.n27 E_CAPTURE_CLKB.n14 0.1205
R1452 E_CAPTURE_CLKB.n23 E_CAPTURE_CLKB.n14 0.1205
R1453 E_CAPTURE_CLKB.n23 E_CAPTURE_CLKB.n22 0.1205
R1454 E_CAPTURE_CLKB.n22 E_CAPTURE_CLKB.n21 0.1205
R1455 E_CAPTURE_CLKB.n21 E_CAPTURE_CLKB.n16 0.1205
R1456 E_CAPTURE_CLKB.n13 E_CAPTURE_CLKB.n0 0.1205
R1457 E_CAPTURE_CLKB.n1 E_CAPTURE_CLKB.n0 0.1205
R1458 E_CAPTURE_CLKB.n2 E_CAPTURE_CLKB.n1 0.1205
R1459 E_CAPTURE_CLKB.n3 E_CAPTURE_CLKB.n2 0.1205
R1460 E_CAPTURE_CLKB.n4 E_CAPTURE_CLKB.n3 0.1205
R1461 VDD.t348 VDD.t347 2823.53
R1462 VDD.t350 VDD.t349 2823.53
R1463 VDD.t349 VDD.t348 1411.76
R1464 VDD.n5 VDD.t406 923.077
R1465 VDD.n6 VDD.t174 923.077
R1466 VDD.n10 VDD.t150 923.077
R1467 VDD.n11 VDD.t170 923.077
R1468 VDD.n15 VDD.t365 923.077
R1469 VDD.n16 VDD.t361 923.077
R1470 VDD.t177 VDD.t408 640.625
R1471 VDD.t153 VDD.t176 640.625
R1472 VDD.t173 VDD.t152 640.625
R1473 VDD.t368 VDD.t172 640.625
R1474 VDD.t364 VDD.t367 640.625
R1475 VDD.t30 VDD.t363 640.625
R1476 VDD.n3 VDD.t406 483.238
R1477 VDD.t174 VDD.n5 461.538
R1478 VDD.n6 VDD.t150 461.538
R1479 VDD.t170 VDD.n10 461.538
R1480 VDD.n11 VDD.t365 461.538
R1481 VDD.t361 VDD.n15 461.538
R1482 VDD.n16 VDD.t27 461.538
R1483 VDD.n28 VDD.t350 407.623
R1484 VDD.n19 VDD.t29 313.94
R1485 VDD.n534 VDD.n263 166.667
R1486 VDD.n536 VDD.n535 166.667
R1487 VDD.n557 VDD.n234 166.667
R1488 VDD.n564 VDD.n563 166.667
R1489 VDD.n406 VDD.n393 166.667
R1490 VDD.n408 VDD.n407 166.667
R1491 VDD.n429 VDD.n363 166.667
R1492 VDD.n436 VDD.n435 166.667
R1493 VDD.n86 VDD.n83 166.667
R1494 VDD.n83 VDD.n82 166.667
R1495 VDD.t42 VDD.n84 126.668
R1496 VDD.n73 VDD.t429 126.668
R1497 VDD.n535 VDD.t374 120.001
R1498 VDD.n234 VDD.t357 120.001
R1499 VDD.n407 VDD.t198 120.001
R1500 VDD.n363 VDD.t441 120.001
R1501 VDD.n543 VDD.t398 113.334
R1502 VDD.t394 VDD.t287 113.334
R1503 VDD.t294 VDD.t359 113.334
R1504 VDD.t202 VDD.n240 113.334
R1505 VDD.n415 VDD.t40 113.334
R1506 VDD.t63 VDD.t93 113.334
R1507 VDD.t100 VDD.t392 113.334
R1508 VDD.t386 VDD.n370 113.334
R1509 VDD.t457 VDD.n108 113.334
R1510 VDD.n100 VDD.t16 113.334
R1511 VDD.t44 VDD.n67 113.334
R1512 VDD.n59 VDD.t215 113.334
R1513 VDD.n529 VDD.n528 106.3
R1514 VDD.n566 VDD.n565 106.3
R1515 VDD.n401 VDD.n400 106.3
R1516 VDD.n438 VDD.n437 106.3
R1517 VDD.n111 VDD.n110 106.3
R1518 VDD.n56 VDD.n55 106.3
R1519 VDD.n536 VDD.t351 80.0005
R1520 VDD.n544 VDD.t285 80.0005
R1521 VDD.n552 VDD.t309 80.0005
R1522 VDD.n557 VDD.t376 80.0005
R1523 VDD.n408 VDD.t455 80.0005
R1524 VDD.n416 VDD.t85 80.0005
R1525 VDD.n424 VDD.t111 80.0005
R1526 VDD.n429 VDD.t388 80.0005
R1527 VDD.n529 VDD.n264 70.0005
R1528 VDD.n533 VDD.n264 70.0005
R1529 VDD.n533 VDD.n258 70.0005
R1530 VDD.n537 VDD.n258 70.0005
R1531 VDD.n537 VDD.n252 70.0005
R1532 VDD.n541 VDD.n252 70.0005
R1533 VDD.n541 VDD.n250 70.0005
R1534 VDD.n546 VDD.n250 70.0005
R1535 VDD.n546 VDD.n237 70.0005
R1536 VDD.n550 VDD.n237 70.0005
R1537 VDD.n550 VDD.n236 70.0005
R1538 VDD.n242 VDD.n236 70.0005
R1539 VDD.n242 VDD.n233 70.0005
R1540 VDD.n558 VDD.n233 70.0005
R1541 VDD.n558 VDD.n228 70.0005
R1542 VDD.n562 VDD.n228 70.0005
R1543 VDD.n562 VDD.n226 70.0005
R1544 VDD.n566 VDD.n226 70.0005
R1545 VDD.n401 VDD.n394 70.0005
R1546 VDD.n405 VDD.n394 70.0005
R1547 VDD.n405 VDD.n388 70.0005
R1548 VDD.n409 VDD.n388 70.0005
R1549 VDD.n409 VDD.n382 70.0005
R1550 VDD.n413 VDD.n382 70.0005
R1551 VDD.n413 VDD.n380 70.0005
R1552 VDD.n418 VDD.n380 70.0005
R1553 VDD.n418 VDD.n367 70.0005
R1554 VDD.n422 VDD.n367 70.0005
R1555 VDD.n422 VDD.n366 70.0005
R1556 VDD.n372 VDD.n366 70.0005
R1557 VDD.n372 VDD.n362 70.0005
R1558 VDD.n430 VDD.n362 70.0005
R1559 VDD.n430 VDD.n356 70.0005
R1560 VDD.n434 VDD.n356 70.0005
R1561 VDD.n434 VDD.n270 70.0005
R1562 VDD.n438 VDD.n270 70.0005
R1563 VDD.n111 VDD.n32 70.0005
R1564 VDD.n107 VDD.n32 70.0005
R1565 VDD.n107 VDD.n33 70.0005
R1566 VDD.n101 VDD.n33 70.0005
R1567 VDD.n101 VDD.n37 70.0005
R1568 VDD.n93 VDD.n37 70.0005
R1569 VDD.n93 VDD.n39 70.0005
R1570 VDD.n87 VDD.n39 70.0005
R1571 VDD.n87 VDD.n43 70.0005
R1572 VDD.n81 VDD.n43 70.0005
R1573 VDD.n81 VDD.n44 70.0005
R1574 VDD.n75 VDD.n44 70.0005
R1575 VDD.n75 VDD.n48 70.0005
R1576 VDD.n66 VDD.n48 70.0005
R1577 VDD.n66 VDD.n50 70.0005
R1578 VDD.n60 VDD.n50 70.0005
R1579 VDD.n60 VDD.n54 70.0005
R1580 VDD.n55 VDD.n54 70.0005
R1581 VDD.n528 VDD.n263 66.6672
R1582 VDD.n565 VDD.n564 66.6672
R1583 VDD.n400 VDD.n393 66.6672
R1584 VDD.n437 VDD.n436 66.6672
R1585 VDD.n110 VDD.n109 66.6672
R1586 VDD.n96 VDD.n95 66.6672
R1587 VDD.n69 VDD.n68 66.6672
R1588 VDD.n57 VDD.n56 66.6672
R1589 VDD.t408 VDD.t409 62.5005
R1590 VDD.t176 VDD.t177 62.5005
R1591 VDD.t152 VDD.t153 62.5005
R1592 VDD.t172 VDD.t173 62.5005
R1593 VDD.t367 VDD.t368 62.5005
R1594 VDD.t363 VDD.t364 62.5005
R1595 VDD.t29 VDD.t30 62.5005
R1596 VDD.n99 VDD.t143 53.3338
R1597 VDD.t416 VDD.n99 53.3338
R1598 VDD.n96 VDD.t245 53.3338
R1599 VDD.n69 VDD.t333 53.3338
R1600 VDD.n58 VDD.t162 53.3338
R1601 VDD.t45 VDD.n58 53.3338
R1602 VDD.n259 VDD.t465 46.6672
R1603 VDD.t372 VDD.n556 46.6672
R1604 VDD.n389 VDD.t443 46.6672
R1605 VDD.t196 VDD.n428 46.6672
R1606 VDD.n84 VDD.t223 46.6672
R1607 VDD.t25 VDD.n73 46.6672
R1608 VDD.n542 VDD.t281 40.0005
R1609 VDD.n241 VDD.t301 40.0005
R1610 VDD.n414 VDD.t65 40.0005
R1611 VDD.n371 VDD.t107 40.0005
R1612 VDD.t14 VDD.t241 33.3338
R1613 VDD.t327 VDD.t34 33.3338
R1614 VDD.t396 VDD.n544 26.6672
R1615 VDD.n552 VDD.t204 26.6672
R1616 VDD.t38 VDD.n416 26.6672
R1617 VDD.n424 VDD.t390 26.6672
R1618 VDD.n86 VDD.t229 26.6672
R1619 VDD.n82 VDD.t431 26.6672
R1620 VDD.n161 VDD.n160 25.203
R1621 VDD.n197 VDD.n196 25.203
R1622 VDD.n21 VDD.t207 25.1121
R1623 VDD.n23 VDD.t471 24.7565
R1624 VDD.n27 VDD.t227 24.7565
R1625 VDD.n24 VDD.t426 24.7565
R1626 VDD.n184 VDD.n183 22.1735
R1627 VDD.n17 VDD.n16 21.6005
R1628 VDD.n15 VDD.n14 21.6005
R1629 VDD.n12 VDD.n11 21.6005
R1630 VDD.n10 VDD.n9 21.6005
R1631 VDD.n7 VDD.n6 21.6005
R1632 VDD.n5 VDD.n4 21.6005
R1633 VDD.n26 VDD.t208 21.4505
R1634 VDD.n25 VDD.t31 21.4505
R1635 VDD.n22 VDD.t149 21.3935
R1636 VDD.n21 VDD.t206 21.3935
R1637 VDD.t192 VDD.n534 20.0005
R1638 VDD.n563 VDD.t353 20.0005
R1639 VDD.t461 VDD.n406 20.0005
R1640 VDD.n435 VDD.t447 20.0005
R1641 VDD.n108 VDD.t139 20.0005
R1642 VDD.n100 VDD.t422 20.0005
R1643 VDD.n67 VDD.t154 20.0005
R1644 VDD.n59 VDD.t47 20.0005
R1645 VDD.n488 VDD.n487 19.9029
R1646 VDD.n291 VDD.n290 19.9029
R1647 VDD.n449 VDD.n448 19.8556
R1648 VDD.n332 VDD.n331 19.8556
R1649 VDD.n146 VDD.n139 19.5039
R1650 VDD.n215 VDD.n208 19.5039
R1651 VDD.n299 VDD.n298 19.4436
R1652 VDD.n458 VDD.n457 19.4435
R1653 VDD.n152 VDD.n150 19.4092
R1654 VDD.n159 VDD.n158 19.4092
R1655 VDD.n200 VDD.n198 19.4092
R1656 VDD.n207 VDD.n206 19.4092
R1657 VDD.n523 VDD.n522 19.0889
R1658 VDD.n273 VDD.n272 19.0889
R1659 VDD.n462 VDD.n461 19.0179
R1660 VDD.n477 VDD.n476 19.0179
R1661 VDD.n515 VDD.n514 19.0179
R1662 VDD.n446 VDD.n445 19.0179
R1663 VDD.n349 VDD.n348 19.0179
R1664 VDD.n278 VDD.n277 19.0179
R1665 VDD.n296 VDD.n295 19.0179
R1666 VDD.n313 VDD.n312 19.0179
R1667 VDD.n113 VDD.n112 18.3116
R1668 VDD.n402 VDD.n399 18.0005
R1669 VDD.n403 VDD.n397 18.0005
R1670 VDD.n404 VDD.n396 18.0005
R1671 VDD.n395 VDD.n387 18.0005
R1672 VDD.n410 VDD.n386 18.0005
R1673 VDD.n411 VDD.n385 18.0005
R1674 VDD.n412 VDD.n384 18.0005
R1675 VDD.n383 VDD.n379 18.0005
R1676 VDD.n419 VDD.n378 18.0005
R1677 VDD.n420 VDD.n377 18.0005
R1678 VDD.n421 VDD.n376 18.0005
R1679 VDD.n375 VDD.n368 18.0005
R1680 VDD.n374 VDD.n373 18.0005
R1681 VDD.n369 VDD.n361 18.0005
R1682 VDD.n431 VDD.n360 18.0005
R1683 VDD.n432 VDD.n359 18.0005
R1684 VDD.n433 VDD.n358 18.0005
R1685 VDD.n357 VDD.n269 18.0005
R1686 VDD.n440 VDD.n439 18.0005
R1687 VDD.n530 VDD.n441 18.0005
R1688 VDD.n531 VDD.n267 18.0005
R1689 VDD.n532 VDD.n266 18.0005
R1690 VDD.n265 VDD.n257 18.0005
R1691 VDD.n538 VDD.n256 18.0005
R1692 VDD.n539 VDD.n255 18.0005
R1693 VDD.n540 VDD.n254 18.0005
R1694 VDD.n253 VDD.n249 18.0005
R1695 VDD.n547 VDD.n248 18.0005
R1696 VDD.n548 VDD.n247 18.0005
R1697 VDD.n549 VDD.n246 18.0005
R1698 VDD.n245 VDD.n238 18.0005
R1699 VDD.n244 VDD.n243 18.0005
R1700 VDD.n239 VDD.n232 18.0005
R1701 VDD.n559 VDD.n231 18.0005
R1702 VDD.n560 VDD.n230 18.0005
R1703 VDD.n561 VDD.n229 18.0005
R1704 VDD.n225 VDD.n224 18.0005
R1705 VDD.n568 VDD.n567 18.0005
R1706 VDD.n31 VDD.n30 18.0005
R1707 VDD.n106 VDD.n105 18.0005
R1708 VDD.n104 VDD.n34 18.0005
R1709 VDD.n103 VDD.n102 18.0005
R1710 VDD.n36 VDD.n35 18.0005
R1711 VDD.n92 VDD.n91 18.0005
R1712 VDD.n90 VDD.n40 18.0005
R1713 VDD.n89 VDD.n88 18.0005
R1714 VDD.n42 VDD.n41 18.0005
R1715 VDD.n80 VDD.n79 18.0005
R1716 VDD.n78 VDD.n45 18.0005
R1717 VDD.n77 VDD.n76 18.0005
R1718 VDD.n47 VDD.n46 18.0005
R1719 VDD.n65 VDD.n64 18.0005
R1720 VDD.n63 VDD.n51 18.0005
R1721 VDD.n62 VDD.n61 18.0005
R1722 VDD.n56 VDD.n49 17.6847
R1723 VDD.n400 VDD.n392 17.639
R1724 VDD.n565 VDD.n227 17.6387
R1725 VDD.n170 VDD.n162 16.9481
R1726 VDD.n485 VDD.n484 16.6701
R1727 VDD.n496 VDD.n495 16.6701
R1728 VDD.n337 VDD.n336 16.6701
R1729 VDD.n326 VDD.n325 16.6701
R1730 VDD.n110 VDD.n29 16.4744
R1731 VDD.n99 VDD.n98 16.4218
R1732 VDD.n97 VDD.n96 16.4218
R1733 VDD.n85 VDD.n38 16.4218
R1734 VDD.n72 VDD.n71 16.4218
R1735 VDD.n70 VDD.n69 16.4218
R1736 VDD.n58 VDD.n49 16.4218
R1737 VDD.n528 VDD.n527 16.3758
R1738 VDD.n535 VDD.n262 16.3758
R1739 VDD.n261 VDD.n260 16.3758
R1740 VDD.n544 VDD.n235 16.3758
R1741 VDD.n553 VDD.n552 16.3758
R1742 VDD.n555 VDD.n554 16.3758
R1743 VDD.n234 VDD.n227 16.3758
R1744 VDD.n407 VDD.n392 16.3758
R1745 VDD.n391 VDD.n390 16.3758
R1746 VDD.n416 VDD.n365 16.3758
R1747 VDD.n425 VDD.n424 16.3758
R1748 VDD.n427 VDD.n426 16.3758
R1749 VDD.n364 VDD.n363 16.3758
R1750 VDD.n437 VDD.n355 16.3756
R1751 VDD.n139 VDD.n138 14.6703
R1752 VDD.n454 VDD.n453 14.4407
R1753 VDD.n321 VDD.n320 14.4407
R1754 VDD.n500 VDD.n499 14.3222
R1755 VDD.n341 VDD.n340 14.3222
R1756 VDD.n134 VDD.n130 13.7564
R1757 VDD.n222 VDD.n221 13.4387
R1758 VDD.t190 VDD.t192 13.3338
R1759 VDD.t374 VDD.t190 13.3338
R1760 VDD.t469 VDD.t351 13.3338
R1761 VDD.t467 VDD.t469 13.3338
R1762 VDD.t465 VDD.t467 13.3338
R1763 VDD.t259 VDD.t273 13.3338
R1764 VDD.t261 VDD.t259 13.3338
R1765 VDD.t275 VDD.t261 13.3338
R1766 VDD.t271 VDD.t275 13.3338
R1767 VDD.t463 VDD.n542 13.3338
R1768 VDD.t221 VDD.t463 13.3338
R1769 VDD.t219 VDD.t221 13.3338
R1770 VDD.t398 VDD.t219 13.3338
R1771 VDD.t263 VDD.n543 13.3338
R1772 VDD.t283 VDD.t263 13.3338
R1773 VDD.t265 VDD.t283 13.3338
R1774 VDD.t285 VDD.t265 13.3338
R1775 VDD.t287 VDD.t288 13.3338
R1776 VDD.t288 VDD.t289 13.3338
R1777 VDD.t289 VDD.t290 13.3338
R1778 VDD.t291 VDD.t292 13.3338
R1779 VDD.t292 VDD.t293 13.3338
R1780 VDD.t293 VDD.t294 13.3338
R1781 VDD.t305 VDD.t309 13.3338
R1782 VDD.t307 VDD.t305 13.3338
R1783 VDD.t311 VDD.t307 13.3338
R1784 VDD.n240 VDD.t311 13.3338
R1785 VDD.t437 VDD.t202 13.3338
R1786 VDD.t435 VDD.t437 13.3338
R1787 VDD.t433 VDD.t435 13.3338
R1788 VDD.n241 VDD.t433 13.3338
R1789 VDD.t317 VDD.t319 13.3338
R1790 VDD.t315 VDD.t317 13.3338
R1791 VDD.t297 VDD.t315 13.3338
R1792 VDD.t321 VDD.t297 13.3338
R1793 VDD.t370 VDD.t372 13.3338
R1794 VDD.t378 VDD.t370 13.3338
R1795 VDD.t376 VDD.t378 13.3338
R1796 VDD.t357 VDD.t355 13.3338
R1797 VDD.t355 VDD.t353 13.3338
R1798 VDD.t459 VDD.t461 13.3338
R1799 VDD.t198 VDD.t459 13.3338
R1800 VDD.t453 VDD.t455 13.3338
R1801 VDD.t445 VDD.t453 13.3338
R1802 VDD.t443 VDD.t445 13.3338
R1803 VDD.t73 VDD.t67 13.3338
R1804 VDD.t77 VDD.t73 13.3338
R1805 VDD.t75 VDD.t77 13.3338
R1806 VDD.t69 VDD.t75 13.3338
R1807 VDD.t213 VDD.n414 13.3338
R1808 VDD.t19 VDD.t213 13.3338
R1809 VDD.t17 VDD.t19 13.3338
R1810 VDD.t40 VDD.t17 13.3338
R1811 VDD.t87 VDD.n415 13.3338
R1812 VDD.t89 VDD.t87 13.3338
R1813 VDD.t91 VDD.t89 13.3338
R1814 VDD.t85 VDD.t91 13.3338
R1815 VDD.t93 VDD.t94 13.3338
R1816 VDD.t94 VDD.t95 13.3338
R1817 VDD.t95 VDD.t96 13.3338
R1818 VDD.t97 VDD.t98 13.3338
R1819 VDD.t98 VDD.t99 13.3338
R1820 VDD.t99 VDD.t100 13.3338
R1821 VDD.t113 VDD.t111 13.3338
R1822 VDD.t115 VDD.t113 13.3338
R1823 VDD.t117 VDD.t115 13.3338
R1824 VDD.n370 VDD.t117 13.3338
R1825 VDD.t384 VDD.t386 13.3338
R1826 VDD.t382 VDD.t384 13.3338
R1827 VDD.t380 VDD.t382 13.3338
R1828 VDD.n371 VDD.t380 13.3338
R1829 VDD.t125 VDD.t121 13.3338
R1830 VDD.t127 VDD.t125 13.3338
R1831 VDD.t123 VDD.t127 13.3338
R1832 VDD.t105 VDD.t123 13.3338
R1833 VDD.t211 VDD.t196 13.3338
R1834 VDD.t209 VDD.t211 13.3338
R1835 VDD.t388 VDD.t209 13.3338
R1836 VDD.t441 VDD.t439 13.3338
R1837 VDD.t439 VDD.t447 13.3338
R1838 VDD.n109 VDD.t233 13.3338
R1839 VDD.t233 VDD.t235 13.3338
R1840 VDD.t235 VDD.t21 13.3338
R1841 VDD.t21 VDD.t457 13.3338
R1842 VDD.t133 VDD.t139 13.3338
R1843 VDD.t135 VDD.t133 13.3338
R1844 VDD.t129 VDD.t135 13.3338
R1845 VDD.t137 VDD.t129 13.3338
R1846 VDD.t141 VDD.t137 13.3338
R1847 VDD.t131 VDD.t141 13.3338
R1848 VDD.t143 VDD.t131 13.3338
R1849 VDD.t410 VDD.t416 13.3338
R1850 VDD.t414 VDD.t410 13.3338
R1851 VDD.t418 VDD.t414 13.3338
R1852 VDD.t412 VDD.t418 13.3338
R1853 VDD.t420 VDD.t412 13.3338
R1854 VDD.t424 VDD.t420 13.3338
R1855 VDD.t422 VDD.t424 13.3338
R1856 VDD.t3 VDD.t16 13.3338
R1857 VDD.t2 VDD.t3 13.3338
R1858 VDD.t24 VDD.t2 13.3338
R1859 VDD.n95 VDD.t24 13.3338
R1860 VDD.t245 VDD.t239 13.3338
R1861 VDD.t239 VDD.t237 13.3338
R1862 VDD.t237 VDD.t184 13.3338
R1863 VDD.t251 VDD.t188 13.3338
R1864 VDD.t243 VDD.t251 13.3338
R1865 VDD.t241 VDD.t243 13.3338
R1866 VDD.t194 VDD.t14 13.3338
R1867 VDD.t427 VDD.t194 13.3338
R1868 VDD.t223 VDD.t427 13.3338
R1869 VDD.t231 VDD.t25 13.3338
R1870 VDD.t32 VDD.t231 13.3338
R1871 VDD.t34 VDD.t32 13.3338
R1872 VDD.t323 VDD.t327 13.3338
R1873 VDD.t325 VDD.t323 13.3338
R1874 VDD.t329 VDD.t325 13.3338
R1875 VDD.t335 VDD.t331 13.3338
R1876 VDD.t337 VDD.t335 13.3338
R1877 VDD.t333 VDD.t337 13.3338
R1878 VDD.n68 VDD.t23 13.3338
R1879 VDD.t23 VDD.t13 13.3338
R1880 VDD.t13 VDD.t12 13.3338
R1881 VDD.t12 VDD.t44 13.3338
R1882 VDD.t160 VDD.t154 13.3338
R1883 VDD.t164 VDD.t160 13.3338
R1884 VDD.t158 VDD.t164 13.3338
R1885 VDD.t168 VDD.t158 13.3338
R1886 VDD.t156 VDD.t168 13.3338
R1887 VDD.t166 VDD.t156 13.3338
R1888 VDD.t162 VDD.t166 13.3338
R1889 VDD.t49 VDD.t45 13.3338
R1890 VDD.t53 VDD.t49 13.3338
R1891 VDD.t57 VDD.t53 13.3338
R1892 VDD.t59 VDD.t57 13.3338
R1893 VDD.t55 VDD.t59 13.3338
R1894 VDD.t51 VDD.t55 13.3338
R1895 VDD.t47 VDD.t51 13.3338
R1896 VDD.t215 VDD.t217 13.3338
R1897 VDD.t217 VDD.t182 13.3338
R1898 VDD.t182 VDD.t4 13.3338
R1899 VDD.t4 VDD.n57 13.3338
R1900 VDD.n171 VDD.n135 13.2291
R1901 VDD.n128 VDD.n115 13.2291
R1902 VDD.n193 VDD.n185 12.3348
R1903 VDD.n149 VDD.n148 11.9744
R1904 VDD.n218 VDD.n217 11.9744
R1905 VDD.n3 VDD.t407 11.724
R1906 VDD.n2 VDD.t175 11.724
R1907 VDD.n8 VDD.t151 11.724
R1908 VDD.n1 VDD.t171 11.724
R1909 VDD.n13 VDD.t366 11.724
R1910 VDD.n0 VDD.t362 11.724
R1911 VDD.n18 VDD.t28 11.724
R1912 VDD.n19 VDD.n18 10.4005
R1913 VDD.n148 VDD.n147 10.1049
R1914 VDD.n217 VDD.n216 10.1049
R1915 VDD.n62 VDD.n52 9.31191
R1916 VDD.n119 VDD.n114 8.84398
R1917 VDD.n473 VDD.n472 8.55306
R1918 VDD.n309 VDD.n308 8.55306
R1919 VDD.n511 VDD.n510 8.42404
R1920 VDD.n289 VDD.n288 8.42404
R1921 VDD.n127 VDD.n119 8.00988
R1922 VDD.n148 VDD.n146 7.43528
R1923 VDD.n217 VDD.n215 7.43528
R1924 VDD.n172 VDD.n129 6.88746
R1925 VDD.n182 VDD.n181 6.88746
R1926 VDD.n195 VDD.n194 6.88746
R1927 VDD.n55 VDD.n52 6.79358
R1928 VDD.t273 VDD.n259 6.66717
R1929 VDD.n260 VDD.t271 6.66717
R1930 VDD.n260 VDD.t277 6.66717
R1931 VDD.t277 VDD.t404 6.66717
R1932 VDD.t404 VDD.t279 6.66717
R1933 VDD.t279 VDD.t402 6.66717
R1934 VDD.t402 VDD.t267 6.66717
R1935 VDD.t267 VDD.t400 6.66717
R1936 VDD.t400 VDD.t269 6.66717
R1937 VDD.t269 VDD.t0 6.66717
R1938 VDD.t0 VDD.t281 6.66717
R1939 VDD.n545 VDD.t396 6.66717
R1940 VDD.n545 VDD.t394 6.66717
R1941 VDD.t290 VDD.n251 6.66717
R1942 VDD.n251 VDD.t291 6.66717
R1943 VDD.n551 VDD.t359 6.66717
R1944 VDD.t204 VDD.n551 6.66717
R1945 VDD.t301 VDD.t10 6.66717
R1946 VDD.t10 VDD.t299 6.66717
R1947 VDD.t299 VDD.t8 6.66717
R1948 VDD.t8 VDD.t303 6.66717
R1949 VDD.t303 VDD.t6 6.66717
R1950 VDD.t6 VDD.t295 6.66717
R1951 VDD.t295 VDD.t36 6.66717
R1952 VDD.t36 VDD.t313 6.66717
R1953 VDD.n555 VDD.t313 6.66717
R1954 VDD.t319 VDD.n555 6.66717
R1955 VDD.n556 VDD.t321 6.66717
R1956 VDD.t67 VDD.n389 6.66717
R1957 VDD.n390 VDD.t69 6.66717
R1958 VDD.n390 VDD.t81 6.66717
R1959 VDD.t81 VDD.t147 6.66717
R1960 VDD.t147 VDD.t79 6.66717
R1961 VDD.t79 VDD.t145 6.66717
R1962 VDD.t145 VDD.t83 6.66717
R1963 VDD.t83 VDD.t180 6.66717
R1964 VDD.t180 VDD.t71 6.66717
R1965 VDD.t71 VDD.t178 6.66717
R1966 VDD.t178 VDD.t65 6.66717
R1967 VDD.n417 VDD.t38 6.66717
R1968 VDD.n417 VDD.t63 6.66717
R1969 VDD.t96 VDD.n381 6.66717
R1970 VDD.n381 VDD.t97 6.66717
R1971 VDD.n423 VDD.t392 6.66717
R1972 VDD.t390 VDD.n423 6.66717
R1973 VDD.t107 VDD.t61 6.66717
R1974 VDD.t61 VDD.t119 6.66717
R1975 VDD.t119 VDD.t474 6.66717
R1976 VDD.t474 VDD.t109 6.66717
R1977 VDD.t109 VDD.t472 6.66717
R1978 VDD.t472 VDD.t101 6.66717
R1979 VDD.t101 VDD.t225 6.66717
R1980 VDD.t225 VDD.t103 6.66717
R1981 VDD.n427 VDD.t103 6.66717
R1982 VDD.t121 VDD.n427 6.66717
R1983 VDD.n428 VDD.t105 6.66717
R1984 VDD.t184 VDD.n94 6.66717
R1985 VDD.n94 VDD.t188 6.66717
R1986 VDD.n85 VDD.t42 6.66717
R1987 VDD.t229 VDD.n85 6.66717
R1988 VDD.n72 VDD.t431 6.66717
R1989 VDD.t429 VDD.n72 6.66717
R1990 VDD.n74 VDD.t329 6.66717
R1991 VDD.n74 VDD.t331 6.66717
R1992 VDD.n571 VDD.n570 6.5855
R1993 VDD.n567 VDD.n566 6.3005
R1994 VDD.n564 VDD.n226 6.3005
R1995 VDD.n226 VDD.n225 6.3005
R1996 VDD.n563 VDD.n562 6.3005
R1997 VDD.n562 VDD.n561 6.3005
R1998 VDD.n234 VDD.n228 6.3005
R1999 VDD.n560 VDD.n228 6.3005
R2000 VDD.n558 VDD.n557 6.3005
R2001 VDD.n559 VDD.n558 6.3005
R2002 VDD.n556 VDD.n233 6.3005
R2003 VDD.n233 VDD.n232 6.3005
R2004 VDD.n242 VDD.n241 6.3005
R2005 VDD.n243 VDD.n242 6.3005
R2006 VDD.n240 VDD.n236 6.3005
R2007 VDD.n238 VDD.n236 6.3005
R2008 VDD.n551 VDD.n550 6.3005
R2009 VDD.n550 VDD.n549 6.3005
R2010 VDD.n251 VDD.n237 6.3005
R2011 VDD.n548 VDD.n237 6.3005
R2012 VDD.n546 VDD.n545 6.3005
R2013 VDD.n547 VDD.n546 6.3005
R2014 VDD.n543 VDD.n250 6.3005
R2015 VDD.n250 VDD.n249 6.3005
R2016 VDD.n542 VDD.n541 6.3005
R2017 VDD.n541 VDD.n540 6.3005
R2018 VDD.n259 VDD.n252 6.3005
R2019 VDD.n539 VDD.n252 6.3005
R2020 VDD.n537 VDD.n536 6.3005
R2021 VDD.n538 VDD.n537 6.3005
R2022 VDD.n535 VDD.n258 6.3005
R2023 VDD.n258 VDD.n257 6.3005
R2024 VDD.n534 VDD.n533 6.3005
R2025 VDD.n533 VDD.n532 6.3005
R2026 VDD.n264 VDD.n263 6.3005
R2027 VDD.n531 VDD.n264 6.3005
R2028 VDD.n530 VDD.n529 6.3005
R2029 VDD.n439 VDD.n438 6.3005
R2030 VDD.n436 VDD.n270 6.3005
R2031 VDD.n270 VDD.n269 6.3005
R2032 VDD.n435 VDD.n434 6.3005
R2033 VDD.n434 VDD.n433 6.3005
R2034 VDD.n363 VDD.n356 6.3005
R2035 VDD.n432 VDD.n356 6.3005
R2036 VDD.n430 VDD.n429 6.3005
R2037 VDD.n431 VDD.n430 6.3005
R2038 VDD.n428 VDD.n362 6.3005
R2039 VDD.n362 VDD.n361 6.3005
R2040 VDD.n372 VDD.n371 6.3005
R2041 VDD.n373 VDD.n372 6.3005
R2042 VDD.n370 VDD.n366 6.3005
R2043 VDD.n368 VDD.n366 6.3005
R2044 VDD.n423 VDD.n422 6.3005
R2045 VDD.n422 VDD.n421 6.3005
R2046 VDD.n381 VDD.n367 6.3005
R2047 VDD.n420 VDD.n367 6.3005
R2048 VDD.n418 VDD.n417 6.3005
R2049 VDD.n419 VDD.n418 6.3005
R2050 VDD.n415 VDD.n380 6.3005
R2051 VDD.n380 VDD.n379 6.3005
R2052 VDD.n414 VDD.n413 6.3005
R2053 VDD.n413 VDD.n412 6.3005
R2054 VDD.n389 VDD.n382 6.3005
R2055 VDD.n411 VDD.n382 6.3005
R2056 VDD.n409 VDD.n408 6.3005
R2057 VDD.n410 VDD.n409 6.3005
R2058 VDD.n407 VDD.n388 6.3005
R2059 VDD.n388 VDD.n387 6.3005
R2060 VDD.n406 VDD.n405 6.3005
R2061 VDD.n405 VDD.n404 6.3005
R2062 VDD.n394 VDD.n393 6.3005
R2063 VDD.n403 VDD.n394 6.3005
R2064 VDD.n402 VDD.n401 6.3005
R2065 VDD.n112 VDD.n111 6.3005
R2066 VDD.n109 VDD.n32 6.3005
R2067 VDD.n32 VDD.n31 6.3005
R2068 VDD.n108 VDD.n107 6.3005
R2069 VDD.n107 VDD.n106 6.3005
R2070 VDD.n99 VDD.n33 6.3005
R2071 VDD.n34 VDD.n33 6.3005
R2072 VDD.n101 VDD.n100 6.3005
R2073 VDD.n102 VDD.n101 6.3005
R2074 VDD.n95 VDD.n37 6.3005
R2075 VDD.n37 VDD.n36 6.3005
R2076 VDD.n94 VDD.n93 6.3005
R2077 VDD.n93 VDD.n92 6.3005
R2078 VDD.n84 VDD.n39 6.3005
R2079 VDD.n40 VDD.n39 6.3005
R2080 VDD.n87 VDD.n86 6.3005
R2081 VDD.n88 VDD.n87 6.3005
R2082 VDD.n83 VDD.n43 6.3005
R2083 VDD.n43 VDD.n42 6.3005
R2084 VDD.n82 VDD.n81 6.3005
R2085 VDD.n81 VDD.n80 6.3005
R2086 VDD.n73 VDD.n44 6.3005
R2087 VDD.n45 VDD.n44 6.3005
R2088 VDD.n75 VDD.n74 6.3005
R2089 VDD.n76 VDD.n75 6.3005
R2090 VDD.n68 VDD.n48 6.3005
R2091 VDD.n48 VDD.n47 6.3005
R2092 VDD.n67 VDD.n66 6.3005
R2093 VDD.n66 VDD.n65 6.3005
R2094 VDD.n58 VDD.n50 6.3005
R2095 VDD.n51 VDD.n50 6.3005
R2096 VDD.n60 VDD.n59 6.3005
R2097 VDD.n61 VDD.n60 6.3005
R2098 VDD.n57 VDD.n54 6.3005
R2099 VDD.n54 VDD.n53 6.3005
R2100 VDD.n457 VDD.t354 5.54817
R2101 VDD.n522 VDD.t375 5.54817
R2102 VDD.n272 VDD.t442 5.54817
R2103 VDD.n298 VDD.t462 5.54817
R2104 VDD.n181 VDD.n180 5.54261
R2105 VDD.n457 VDD.n456 5.51014
R2106 VDD.n461 VDD.n460 5.51014
R2107 VDD.n466 VDD.n464 5.51014
R2108 VDD.n453 VDD.n451 5.51014
R2109 VDD.n484 VDD.n483 5.51014
R2110 VDD.n495 VDD.n494 5.51014
R2111 VDD.n499 VDD.n498 5.51014
R2112 VDD.n504 VDD.n502 5.51014
R2113 VDD.n514 VDD.n513 5.51014
R2114 VDD.n445 VDD.n444 5.51014
R2115 VDD.n522 VDD.n521 5.51014
R2116 VDD.n272 VDD.n271 5.51014
R2117 VDD.n348 VDD.n346 5.51014
R2118 VDD.n277 VDD.n275 5.51014
R2119 VDD.n282 VDD.n280 5.51014
R2120 VDD.n340 VDD.n338 5.51014
R2121 VDD.n336 VDD.n334 5.51014
R2122 VDD.n325 VDD.n323 5.51014
R2123 VDD.n320 VDD.n318 5.51014
R2124 VDD.n302 VDD.n300 5.51014
R2125 VDD.n312 VDD.n310 5.51014
R2126 VDD.n298 VDD.n297 5.51014
R2127 VDD.n138 VDD.n136 5.51014
R2128 VDD.n142 VDD.n140 5.51014
R2129 VDD.n155 VDD.n153 5.51014
R2130 VDD.n133 VDD.n131 5.51014
R2131 VDD.n165 VDD.n163 5.51014
R2132 VDD.n118 VDD.n116 5.51014
R2133 VDD.n122 VDD.n120 5.51014
R2134 VDD.n188 VDD.n186 5.51014
R2135 VDD.n203 VDD.n201 5.51014
R2136 VDD.n211 VDD.n209 5.51014
R2137 VDD.n221 VDD.n219 5.51014
R2138 VDD.n476 VDD.n474 5.43909
R2139 VDD.n295 VDD.n294 5.43909
R2140 VDD.n476 VDD.n475 5.39172
R2141 VDD.n295 VDD.n293 5.39172
R2142 VDD.n461 VDD.n459 5.32067
R2143 VDD.n472 VDD.n471 5.32067
R2144 VDD.n470 VDD.n469 5.32067
R2145 VDD.n468 VDD.n467 5.32067
R2146 VDD.n466 VDD.n465 5.32067
R2147 VDD.n453 VDD.n452 5.32067
R2148 VDD.n484 VDD.n482 5.32067
R2149 VDD.n495 VDD.n493 5.32067
R2150 VDD.n499 VDD.n497 5.32067
R2151 VDD.n510 VDD.n509 5.32067
R2152 VDD.n508 VDD.n507 5.32067
R2153 VDD.n506 VDD.n505 5.32067
R2154 VDD.n504 VDD.n503 5.32067
R2155 VDD.n514 VDD.n512 5.32067
R2156 VDD.n445 VDD.n443 5.32067
R2157 VDD.n348 VDD.n347 5.32067
R2158 VDD.n277 VDD.n276 5.32067
R2159 VDD.n282 VDD.n281 5.32067
R2160 VDD.n284 VDD.n283 5.32067
R2161 VDD.n286 VDD.n285 5.32067
R2162 VDD.n288 VDD.n287 5.32067
R2163 VDD.n340 VDD.n339 5.32067
R2164 VDD.n336 VDD.n335 5.32067
R2165 VDD.n325 VDD.n324 5.32067
R2166 VDD.n320 VDD.n319 5.32067
R2167 VDD.n302 VDD.n301 5.32067
R2168 VDD.n304 VDD.n303 5.32067
R2169 VDD.n306 VDD.n305 5.32067
R2170 VDD.n308 VDD.n307 5.32067
R2171 VDD.n312 VDD.n311 5.32067
R2172 VDD.n138 VDD.n137 5.32067
R2173 VDD.n146 VDD.n145 5.32067
R2174 VDD.n144 VDD.n143 5.32067
R2175 VDD.n142 VDD.n141 5.32067
R2176 VDD.n152 VDD.n151 5.32067
R2177 VDD.n157 VDD.n156 5.32067
R2178 VDD.n155 VDD.n154 5.32067
R2179 VDD.n133 VDD.n132 5.32067
R2180 VDD.n174 VDD.n173 5.32067
R2181 VDD.n176 VDD.n175 5.32067
R2182 VDD.n178 VDD.n177 5.32067
R2183 VDD.n180 VDD.n179 5.32067
R2184 VDD.n169 VDD.n168 5.32067
R2185 VDD.n167 VDD.n166 5.32067
R2186 VDD.n165 VDD.n164 5.32067
R2187 VDD.n118 VDD.n117 5.32067
R2188 VDD.n126 VDD.n125 5.32067
R2189 VDD.n124 VDD.n123 5.32067
R2190 VDD.n122 VDD.n121 5.32067
R2191 VDD.n192 VDD.n191 5.32067
R2192 VDD.n190 VDD.n189 5.32067
R2193 VDD.n188 VDD.n187 5.32067
R2194 VDD.n200 VDD.n199 5.32067
R2195 VDD.n205 VDD.n204 5.32067
R2196 VDD.n203 VDD.n202 5.32067
R2197 VDD.n215 VDD.n214 5.32067
R2198 VDD.n213 VDD.n212 5.32067
R2199 VDD.n211 VDD.n210 5.32067
R2200 VDD.n221 VDD.n220 5.32067
R2201 VDD.n223 VDD.n222 5.28208
R2202 VDD.n172 VDD.n171 5.08746
R2203 VDD.n194 VDD.n128 5.08746
R2204 VDD.n134 VDD.n133 5.02155
R2205 VDD.n20 VDD.n19 4.901
R2206 VDD.n174 VDD.n172 4.68997
R2207 VDD.n119 VDD.n118 4.54787
R2208 VDD.n520 VDD.n442 4.5005
R2209 VDD.n519 VDD.n518 4.5005
R2210 VDD.n517 VDD.n516 4.5005
R2211 VDD.n501 VDD.n447 4.5005
R2212 VDD.n492 VDD.n491 4.5005
R2213 VDD.n490 VDD.n489 4.5005
R2214 VDD.n486 VDD.n450 4.5005
R2215 VDD.n481 VDD.n480 4.5005
R2216 VDD.n479 VDD.n478 4.5005
R2217 VDD.n463 VDD.n455 4.5005
R2218 VDD.n328 VDD.n327 4.5005
R2219 VDD.n315 VDD.n314 4.5005
R2220 VDD.n317 VDD.n316 4.5005
R2221 VDD.n322 VDD.n292 4.5005
R2222 VDD.n330 VDD.n329 4.5005
R2223 VDD.n333 VDD.n279 4.5005
R2224 VDD.n343 VDD.n342 4.5005
R2225 VDD.n345 VDD.n344 4.5005
R2226 VDD.n350 VDD.n274 4.5005
R2227 VDD.n352 VDD.n351 4.5005
R2228 VDD.n171 VDD.n170 4.5005
R2229 VDD.n194 VDD.n193 4.5005
R2230 VDD.n128 VDD.n127 4.5005
R2231 VDD.n569 VDD.n223 4.1605
R2232 VDD.n184 VDD.n182 3.26892
R2233 VDD.n398 VDD.n20 3.2505
R2234 VDD.n398 VDD.n223 3.0005
R2235 VDD.n524 VDD.n523 2.48765
R2236 VDD.n353 VDD.n273 2.48765
R2237 VDD.n570 VDD.n28 2.2685
R2238 VDD.n181 VDD.n134 1.95702
R2239 VDD.n182 VDD.n129 1.8005
R2240 VDD.n315 VDD.n299 1.76137
R2241 VDD.n458 VDD.n455 1.76125
R2242 VDD.n198 VDD.n197 1.61103
R2243 VDD.n570 VDD.n569 1.5955
R2244 VDD.n222 VDD.n218 1.51629
R2245 VDD.n197 VDD.n195 1.42155
R2246 VDD.n150 VDD.n149 1.42155
R2247 VDD.n462 VDD.n458 1.39974
R2248 VDD.n313 VDD.n299 1.39971
R2249 VDD.n527 VDD.n262 1.26366
R2250 VDD.n262 VDD.n261 1.26366
R2251 VDD.n261 VDD.n235 1.26366
R2252 VDD.n553 VDD.n235 1.26366
R2253 VDD.n554 VDD.n553 1.26366
R2254 VDD.n554 VDD.n227 1.26366
R2255 VDD.n392 VDD.n391 1.26366
R2256 VDD.n391 VDD.n365 1.26366
R2257 VDD.n425 VDD.n365 1.26366
R2258 VDD.n426 VDD.n425 1.26366
R2259 VDD.n426 VDD.n364 1.26366
R2260 VDD.n364 VDD.n355 1.26366
R2261 VDD.n98 VDD.n97 1.26366
R2262 VDD.n97 VDD.n38 1.26366
R2263 VDD.n71 VDD.n38 1.26366
R2264 VDD.n71 VDD.n70 1.26366
R2265 VDD.n70 VDD.n49 1.26366
R2266 VDD.n208 VDD.n207 1.23208
R2267 VDD.n98 VDD.n29 1.21103
R2268 VDD.n161 VDD.n159 1.13734
R2269 VDD.n185 VDD.n184 1.08997
R2270 VDD.n531 VDD.n530 1.0005
R2271 VDD.n532 VDD.n531 1.0005
R2272 VDD.n532 VDD.n257 1.0005
R2273 VDD.n538 VDD.n257 1.0005
R2274 VDD.n539 VDD.n538 1.0005
R2275 VDD.n540 VDD.n539 1.0005
R2276 VDD.n540 VDD.n249 1.0005
R2277 VDD.n547 VDD.n249 1.0005
R2278 VDD.n548 VDD.n547 1.0005
R2279 VDD.n549 VDD.n548 1.0005
R2280 VDD.n549 VDD.n238 1.0005
R2281 VDD.n243 VDD.n238 1.0005
R2282 VDD.n243 VDD.n232 1.0005
R2283 VDD.n559 VDD.n232 1.0005
R2284 VDD.n560 VDD.n559 1.0005
R2285 VDD.n561 VDD.n560 1.0005
R2286 VDD.n561 VDD.n225 1.0005
R2287 VDD.n567 VDD.n225 1.0005
R2288 VDD.n403 VDD.n402 1.0005
R2289 VDD.n404 VDD.n403 1.0005
R2290 VDD.n404 VDD.n387 1.0005
R2291 VDD.n410 VDD.n387 1.0005
R2292 VDD.n411 VDD.n410 1.0005
R2293 VDD.n412 VDD.n411 1.0005
R2294 VDD.n412 VDD.n379 1.0005
R2295 VDD.n419 VDD.n379 1.0005
R2296 VDD.n420 VDD.n419 1.0005
R2297 VDD.n421 VDD.n420 1.0005
R2298 VDD.n421 VDD.n368 1.0005
R2299 VDD.n373 VDD.n368 1.0005
R2300 VDD.n373 VDD.n361 1.0005
R2301 VDD.n431 VDD.n361 1.0005
R2302 VDD.n432 VDD.n431 1.0005
R2303 VDD.n433 VDD.n432 1.0005
R2304 VDD.n433 VDD.n269 1.0005
R2305 VDD.n439 VDD.n269 1.0005
R2306 VDD.n112 VDD.n31 1.0005
R2307 VDD.n106 VDD.n31 1.0005
R2308 VDD.n106 VDD.n34 1.0005
R2309 VDD.n102 VDD.n34 1.0005
R2310 VDD.n102 VDD.n36 1.0005
R2311 VDD.n92 VDD.n36 1.0005
R2312 VDD.n92 VDD.n40 1.0005
R2313 VDD.n88 VDD.n40 1.0005
R2314 VDD.n88 VDD.n42 1.0005
R2315 VDD.n80 VDD.n42 1.0005
R2316 VDD.n80 VDD.n45 1.0005
R2317 VDD.n76 VDD.n45 1.0005
R2318 VDD.n76 VDD.n47 1.0005
R2319 VDD.n65 VDD.n47 1.0005
R2320 VDD.n65 VDD.n51 1.0005
R2321 VDD.n61 VDD.n51 1.0005
R2322 VDD.n61 VDD.n53 1.0005
R2323 VDD.n162 VDD.n161 0.947868
R2324 VDD.n520 VDD.n519 0.9005
R2325 VDD.n351 VDD.n350 0.9005
R2326 VDD.n489 VDD.n488 0.8855
R2327 VDD.n330 VDD.n291 0.8855
R2328 VDD.n486 VDD.n485 0.8105
R2329 VDD.n327 VDD.n326 0.8105
R2330 VDD.n4 VDD.n3 0.8005
R2331 VDD.n7 VDD.n2 0.8005
R2332 VDD.n9 VDD.n8 0.8005
R2333 VDD.n12 VDD.n1 0.8005
R2334 VDD.n14 VDD.n13 0.8005
R2335 VDD.n17 VDD.n0 0.8005
R2336 VDD.n500 VDD.n496 0.7505
R2337 VDD.n341 VDD.n337 0.7505
R2338 VDD.n481 VDD.n454 0.7355
R2339 VDD.n322 VDD.n321 0.7355
R2340 VDD.n519 VDD.n446 0.6605
R2341 VDD.n350 VDD.n349 0.6605
R2342 VDD.n477 VDD.n473 0.622051
R2343 VDD.n309 VDD.n296 0.622051
R2344 VDD.n524 VDD.n442 0.608067
R2345 VDD.n353 VDD.n352 0.608067
R2346 VDD.n492 VDD.n449 0.5855
R2347 VDD.n333 VDD.n332 0.5855
R2348 VDD.n185 VDD.n114 0.568921
R2349 VDD.n441 VDD.n440 0.5605
R2350 VDD.n516 VDD.n515 0.5105
R2351 VDD.n345 VDD.n278 0.5105
R2352 VDD.n53 VDD.n52 0.481712
R2353 VDD.n162 VDD.n129 0.474184
R2354 VDD.n105 VDD.n30 0.444944
R2355 VDD.n105 VDD.n104 0.444944
R2356 VDD.n104 VDD.n103 0.444944
R2357 VDD.n103 VDD.n35 0.444944
R2358 VDD.n91 VDD.n35 0.444944
R2359 VDD.n91 VDD.n90 0.444944
R2360 VDD.n90 VDD.n89 0.444944
R2361 VDD.n89 VDD.n41 0.444944
R2362 VDD.n79 VDD.n41 0.444944
R2363 VDD.n79 VDD.n78 0.444944
R2364 VDD.n78 VDD.n77 0.444944
R2365 VDD.n77 VDD.n46 0.444944
R2366 VDD.n64 VDD.n46 0.444944
R2367 VDD.n64 VDD.n63 0.444944
R2368 VDD.n63 VDD.n62 0.444944
R2369 VDD.n24 VDD.n23 0.4305
R2370 VDD.n518 VDD.n442 0.4005
R2371 VDD.n518 VDD.n517 0.4005
R2372 VDD.n517 VDD.n447 0.4005
R2373 VDD.n491 VDD.n447 0.4005
R2374 VDD.n491 VDD.n490 0.4005
R2375 VDD.n490 VDD.n450 0.4005
R2376 VDD.n480 VDD.n450 0.4005
R2377 VDD.n480 VDD.n479 0.4005
R2378 VDD.n479 VDD.n455 0.4005
R2379 VDD.n316 VDD.n315 0.4005
R2380 VDD.n316 VDD.n292 0.4005
R2381 VDD.n328 VDD.n292 0.4005
R2382 VDD.n329 VDD.n328 0.4005
R2383 VDD.n329 VDD.n279 0.4005
R2384 VDD.n343 VDD.n279 0.4005
R2385 VDD.n344 VDD.n343 0.4005
R2386 VDD.n344 VDD.n274 0.4005
R2387 VDD.n352 VDD.n274 0.4005
R2388 VDD.n195 VDD.n114 0.379447
R2389 VDD.n22 VDD.n21 0.356056
R2390 VDD.n23 VDD.n22 0.356056
R2391 VDD.n399 VDD.n398 0.3305
R2392 VDD.n569 VDD.n568 0.3305
R2393 VDD.n489 VDD.n449 0.3155
R2394 VDD.n332 VDD.n330 0.3155
R2395 VDD.n527 VDD.n526 0.264711
R2396 VDD.n355 VDD.n354 0.264711
R2397 VDD.n342 VDD.n289 0.256124
R2398 VDD.n511 VDD.n501 0.256124
R2399 VDD.n516 VDD.n446 0.2405
R2400 VDD.n349 VDD.n345 0.2405
R2401 VDD.n456 VDD.t358 0.228
R2402 VDD.n456 VDD.t356 0.228
R2403 VDD.n459 VDD.t379 0.228
R2404 VDD.n459 VDD.t377 0.228
R2405 VDD.n460 VDD.t373 0.228
R2406 VDD.n460 VDD.t371 0.228
R2407 VDD.n471 VDD.t298 0.228
R2408 VDD.n471 VDD.t322 0.228
R2409 VDD.n469 VDD.t318 0.228
R2410 VDD.n469 VDD.t316 0.228
R2411 VDD.n467 VDD.t314 0.228
R2412 VDD.n467 VDD.t320 0.228
R2413 VDD.n465 VDD.t304 0.228
R2414 VDD.n465 VDD.t296 0.228
R2415 VDD.n464 VDD.t302 0.228
R2416 VDD.n464 VDD.t300 0.228
R2417 VDD.n474 VDD.t7 0.228
R2418 VDD.n474 VDD.t37 0.228
R2419 VDD.n475 VDD.t11 0.228
R2420 VDD.n475 VDD.t9 0.228
R2421 VDD.n452 VDD.t436 0.228
R2422 VDD.n452 VDD.t434 0.228
R2423 VDD.n451 VDD.t203 0.228
R2424 VDD.n451 VDD.t438 0.228
R2425 VDD.n482 VDD.t308 0.228
R2426 VDD.n482 VDD.t312 0.228
R2427 VDD.n483 VDD.t310 0.228
R2428 VDD.n483 VDD.t306 0.228
R2429 VDD.n487 VDD.t360 0.228
R2430 VDD.n487 VDD.t205 0.228
R2431 VDD.n448 VDD.t397 0.228
R2432 VDD.n448 VDD.t395 0.228
R2433 VDD.n493 VDD.t266 0.228
R2434 VDD.n493 VDD.t286 0.228
R2435 VDD.n494 VDD.t264 0.228
R2436 VDD.n494 VDD.t284 0.228
R2437 VDD.n497 VDD.t220 0.228
R2438 VDD.n497 VDD.t399 0.228
R2439 VDD.n498 VDD.t464 0.228
R2440 VDD.n498 VDD.t222 0.228
R2441 VDD.n509 VDD.t270 0.228
R2442 VDD.n509 VDD.t282 0.228
R2443 VDD.n507 VDD.t280 0.228
R2444 VDD.n507 VDD.t268 0.228
R2445 VDD.n505 VDD.t272 0.228
R2446 VDD.n505 VDD.t278 0.228
R2447 VDD.n503 VDD.t262 0.228
R2448 VDD.n503 VDD.t276 0.228
R2449 VDD.n502 VDD.t274 0.228
R2450 VDD.n502 VDD.t260 0.228
R2451 VDD.n512 VDD.t401 0.228
R2452 VDD.n512 VDD.t1 0.228
R2453 VDD.n513 VDD.t405 0.228
R2454 VDD.n513 VDD.t403 0.228
R2455 VDD.n443 VDD.t468 0.228
R2456 VDD.n443 VDD.t466 0.228
R2457 VDD.n444 VDD.t352 0.228
R2458 VDD.n444 VDD.t470 0.228
R2459 VDD.n521 VDD.t193 0.228
R2460 VDD.n521 VDD.t191 0.228
R2461 VDD.n271 VDD.t440 0.228
R2462 VDD.n271 VDD.t448 0.228
R2463 VDD.n346 VDD.t210 0.228
R2464 VDD.n346 VDD.t389 0.228
R2465 VDD.n347 VDD.t197 0.228
R2466 VDD.n347 VDD.t212 0.228
R2467 VDD.n275 VDD.t473 0.228
R2468 VDD.n275 VDD.t226 0.228
R2469 VDD.n276 VDD.t62 0.228
R2470 VDD.n276 VDD.t475 0.228
R2471 VDD.n280 VDD.t124 0.228
R2472 VDD.n280 VDD.t106 0.228
R2473 VDD.n281 VDD.t126 0.228
R2474 VDD.n281 VDD.t128 0.228
R2475 VDD.n283 VDD.t104 0.228
R2476 VDD.n283 VDD.t122 0.228
R2477 VDD.n285 VDD.t110 0.228
R2478 VDD.n285 VDD.t102 0.228
R2479 VDD.n287 VDD.t108 0.228
R2480 VDD.n287 VDD.t120 0.228
R2481 VDD.n338 VDD.t383 0.228
R2482 VDD.n338 VDD.t381 0.228
R2483 VDD.n339 VDD.t387 0.228
R2484 VDD.n339 VDD.t385 0.228
R2485 VDD.n334 VDD.t116 0.228
R2486 VDD.n334 VDD.t118 0.228
R2487 VDD.n335 VDD.t112 0.228
R2488 VDD.n335 VDD.t114 0.228
R2489 VDD.n331 VDD.t393 0.228
R2490 VDD.n331 VDD.t391 0.228
R2491 VDD.n290 VDD.t39 0.228
R2492 VDD.n290 VDD.t64 0.228
R2493 VDD.n323 VDD.t92 0.228
R2494 VDD.n323 VDD.t86 0.228
R2495 VDD.n324 VDD.t88 0.228
R2496 VDD.n324 VDD.t90 0.228
R2497 VDD.n318 VDD.t18 0.228
R2498 VDD.n318 VDD.t41 0.228
R2499 VDD.n319 VDD.t214 0.228
R2500 VDD.n319 VDD.t20 0.228
R2501 VDD.n293 VDD.t181 0.228
R2502 VDD.n293 VDD.t179 0.228
R2503 VDD.n294 VDD.t148 0.228
R2504 VDD.n294 VDD.t146 0.228
R2505 VDD.n300 VDD.t72 0.228
R2506 VDD.n300 VDD.t66 0.228
R2507 VDD.n301 VDD.t80 0.228
R2508 VDD.n301 VDD.t84 0.228
R2509 VDD.n303 VDD.t70 0.228
R2510 VDD.n303 VDD.t82 0.228
R2511 VDD.n305 VDD.t78 0.228
R2512 VDD.n305 VDD.t76 0.228
R2513 VDD.n307 VDD.t68 0.228
R2514 VDD.n307 VDD.t74 0.228
R2515 VDD.n310 VDD.t446 0.228
R2516 VDD.n310 VDD.t444 0.228
R2517 VDD.n311 VDD.t456 0.228
R2518 VDD.n311 VDD.t454 0.228
R2519 VDD.n297 VDD.t460 0.228
R2520 VDD.n297 VDD.t199 0.228
R2521 VDD.n137 VDD.t183 0.228
R2522 VDD.n137 VDD.t5 0.228
R2523 VDD.n136 VDD.t216 0.228
R2524 VDD.n136 VDD.t218 0.228
R2525 VDD.n147 VDD.t450 0.228
R2526 VDD.n147 VDD.t449 0.228
R2527 VDD.n145 VDD.t52 0.228
R2528 VDD.n145 VDD.t48 0.228
R2529 VDD.n143 VDD.t60 0.228
R2530 VDD.n143 VDD.t56 0.228
R2531 VDD.n141 VDD.t54 0.228
R2532 VDD.n141 VDD.t58 0.228
R2533 VDD.n140 VDD.t46 0.228
R2534 VDD.n140 VDD.t50 0.228
R2535 VDD.n151 VDD.t167 0.228
R2536 VDD.n151 VDD.t163 0.228
R2537 VDD.n156 VDD.t169 0.228
R2538 VDD.n156 VDD.t157 0.228
R2539 VDD.n154 VDD.t165 0.228
R2540 VDD.n154 VDD.t159 0.228
R2541 VDD.n153 VDD.t155 0.228
R2542 VDD.n153 VDD.t161 0.228
R2543 VDD.n160 VDD.t201 0.228
R2544 VDD.n160 VDD.t200 0.228
R2545 VDD.n135 VDD.t452 0.228
R2546 VDD.n135 VDD.t451 0.228
R2547 VDD.n130 VDD.t432 0.228
R2548 VDD.n130 VDD.t430 0.228
R2549 VDD.n131 VDD.t33 0.228
R2550 VDD.n131 VDD.t35 0.228
R2551 VDD.n132 VDD.t26 0.228
R2552 VDD.n132 VDD.t232 0.228
R2553 VDD.n173 VDD.t338 0.228
R2554 VDD.n173 VDD.t334 0.228
R2555 VDD.n175 VDD.t332 0.228
R2556 VDD.n175 VDD.t336 0.228
R2557 VDD.n177 VDD.t326 0.228
R2558 VDD.n177 VDD.t330 0.228
R2559 VDD.n179 VDD.t328 0.228
R2560 VDD.n179 VDD.t324 0.228
R2561 VDD.n168 VDD.t346 0.228
R2562 VDD.n168 VDD.t339 0.228
R2563 VDD.n166 VDD.t344 0.228
R2564 VDD.n166 VDD.t345 0.228
R2565 VDD.n164 VDD.t342 0.228
R2566 VDD.n164 VDD.t343 0.228
R2567 VDD.n163 VDD.t340 0.228
R2568 VDD.n163 VDD.t341 0.228
R2569 VDD.n183 VDD.t43 0.228
R2570 VDD.n183 VDD.t230 0.228
R2571 VDD.n115 VDD.t185 0.228
R2572 VDD.n115 VDD.t189 0.228
R2573 VDD.n117 VDD.t428 0.228
R2574 VDD.n117 VDD.t224 0.228
R2575 VDD.n116 VDD.t15 0.228
R2576 VDD.n116 VDD.t195 0.228
R2577 VDD.n125 VDD.t258 0.228
R2578 VDD.n125 VDD.t242 0.228
R2579 VDD.n123 VDD.t255 0.228
R2580 VDD.n123 VDD.t257 0.228
R2581 VDD.n121 VDD.t238 0.228
R2582 VDD.n121 VDD.t256 0.228
R2583 VDD.n120 VDD.t246 0.228
R2584 VDD.n120 VDD.t254 0.228
R2585 VDD.n191 VDD.t244 0.228
R2586 VDD.n191 VDD.t253 0.228
R2587 VDD.n189 VDD.t247 0.228
R2588 VDD.n189 VDD.t252 0.228
R2589 VDD.n187 VDD.t248 0.228
R2590 VDD.n187 VDD.t250 0.228
R2591 VDD.n186 VDD.t249 0.228
R2592 VDD.n186 VDD.t240 0.228
R2593 VDD.n196 VDD.t228 0.228
R2594 VDD.n196 VDD.t369 0.228
R2595 VDD.n199 VDD.t425 0.228
R2596 VDD.n199 VDD.t423 0.228
R2597 VDD.n204 VDD.t413 0.228
R2598 VDD.n204 VDD.t421 0.228
R2599 VDD.n202 VDD.t415 0.228
R2600 VDD.n202 VDD.t419 0.228
R2601 VDD.n201 VDD.t417 0.228
R2602 VDD.n201 VDD.t411 0.228
R2603 VDD.n216 VDD.t187 0.228
R2604 VDD.n216 VDD.t186 0.228
R2605 VDD.n214 VDD.t132 0.228
R2606 VDD.n214 VDD.t144 0.228
R2607 VDD.n212 VDD.t138 0.228
R2608 VDD.n212 VDD.t142 0.228
R2609 VDD.n210 VDD.t136 0.228
R2610 VDD.n210 VDD.t130 0.228
R2611 VDD.n209 VDD.t140 0.228
R2612 VDD.n209 VDD.t134 0.228
R2613 VDD.n220 VDD.t22 0.228
R2614 VDD.n220 VDD.t458 0.228
R2615 VDD.n219 VDD.t234 0.228
R2616 VDD.n219 VDD.t236 0.228
R2617 VDD.n468 VDD.n466 0.189974
R2618 VDD.n470 VDD.n468 0.189974
R2619 VDD.n472 VDD.n470 0.189974
R2620 VDD.n506 VDD.n504 0.189974
R2621 VDD.n508 VDD.n506 0.189974
R2622 VDD.n510 VDD.n508 0.189974
R2623 VDD.n288 VDD.n286 0.189974
R2624 VDD.n286 VDD.n284 0.189974
R2625 VDD.n284 VDD.n282 0.189974
R2626 VDD.n308 VDD.n306 0.189974
R2627 VDD.n306 VDD.n304 0.189974
R2628 VDD.n304 VDD.n302 0.189974
R2629 VDD.n144 VDD.n142 0.189974
R2630 VDD.n146 VDD.n144 0.189974
R2631 VDD.n157 VDD.n155 0.189974
R2632 VDD.n167 VDD.n165 0.189974
R2633 VDD.n169 VDD.n167 0.189974
R2634 VDD.n170 VDD.n169 0.189974
R2635 VDD.n180 VDD.n178 0.189974
R2636 VDD.n178 VDD.n176 0.189974
R2637 VDD.n176 VDD.n174 0.189974
R2638 VDD.n190 VDD.n188 0.189974
R2639 VDD.n192 VDD.n190 0.189974
R2640 VDD.n193 VDD.n192 0.189974
R2641 VDD.n124 VDD.n122 0.189974
R2642 VDD.n126 VDD.n124 0.189974
R2643 VDD.n127 VDD.n126 0.189974
R2644 VDD.n205 VDD.n203 0.189974
R2645 VDD.n213 VDD.n211 0.189974
R2646 VDD.n215 VDD.n213 0.189974
R2647 VDD.n523 VDD.n520 0.1655
R2648 VDD.n478 VDD.n454 0.1655
R2649 VDD.n321 VDD.n317 0.1655
R2650 VDD.n351 VDD.n273 0.1655
R2651 VDD.n473 VDD.n463 0.143825
R2652 VDD.n314 VDD.n309 0.143825
R2653 VDD.n526 VDD.n524 0.143727
R2654 VDD.n354 VDD.n353 0.143727
R2655 VDD.n478 VDD.n477 0.1355
R2656 VDD.n317 VDD.n296 0.1355
R2657 VDD.n515 VDD.n511 0.135448
R2658 VDD.n289 VDD.n278 0.135448
R2659 VDD.n113 VDD.n30 0.133833
R2660 VDD.n571 VDD.n20 0.1105
R2661 VDD.n4 VDD.n2 0.1005
R2662 VDD.n8 VDD.n7 0.1005
R2663 VDD.n9 VDD.n1 0.1005
R2664 VDD.n13 VDD.n12 0.1005
R2665 VDD.n14 VDD.n0 0.1005
R2666 VDD.n18 VDD.n17 0.1005
R2667 VDD.n399 VDD.n397 0.1005
R2668 VDD.n397 VDD.n396 0.1005
R2669 VDD.n396 VDD.n395 0.1005
R2670 VDD.n395 VDD.n386 0.1005
R2671 VDD.n386 VDD.n385 0.1005
R2672 VDD.n385 VDD.n384 0.1005
R2673 VDD.n384 VDD.n383 0.1005
R2674 VDD.n383 VDD.n378 0.1005
R2675 VDD.n378 VDD.n377 0.1005
R2676 VDD.n377 VDD.n376 0.1005
R2677 VDD.n376 VDD.n375 0.1005
R2678 VDD.n375 VDD.n374 0.1005
R2679 VDD.n374 VDD.n369 0.1005
R2680 VDD.n369 VDD.n360 0.1005
R2681 VDD.n360 VDD.n359 0.1005
R2682 VDD.n359 VDD.n358 0.1005
R2683 VDD.n358 VDD.n357 0.1005
R2684 VDD.n267 VDD.n266 0.1005
R2685 VDD.n266 VDD.n265 0.1005
R2686 VDD.n265 VDD.n256 0.1005
R2687 VDD.n256 VDD.n255 0.1005
R2688 VDD.n255 VDD.n254 0.1005
R2689 VDD.n254 VDD.n253 0.1005
R2690 VDD.n253 VDD.n248 0.1005
R2691 VDD.n248 VDD.n247 0.1005
R2692 VDD.n247 VDD.n246 0.1005
R2693 VDD.n246 VDD.n245 0.1005
R2694 VDD.n245 VDD.n244 0.1005
R2695 VDD.n244 VDD.n239 0.1005
R2696 VDD.n239 VDD.n231 0.1005
R2697 VDD.n231 VDD.n230 0.1005
R2698 VDD.n230 VDD.n229 0.1005
R2699 VDD.n229 VDD.n224 0.1005
R2700 VDD.n568 VDD.n224 0.1005
R2701 VDD.n218 VDD.n208 0.0952368
R2702 VDD.n207 VDD.n198 0.0952368
R2703 VDD.n159 VDD.n150 0.0952368
R2704 VDD.n149 VDD.n139 0.0952368
R2705 VDD.n158 VDD.n157 0.0952368
R2706 VDD.n158 VDD.n152 0.0952368
R2707 VDD.n206 VDD.n205 0.0952368
R2708 VDD.n206 VDD.n200 0.0952368
R2709 VDD.n496 VDD.n492 0.0905
R2710 VDD.n485 VDD.n481 0.0905
R2711 VDD.n326 VDD.n322 0.0905
R2712 VDD.n337 VDD.n333 0.0905
R2713 VDD.n25 VDD.n24 0.0805
R2714 VDD.n26 VDD.n25 0.0805
R2715 VDD.n27 VDD.n26 0.0805
R2716 VDD.n526 VDD.n525 0.0741842
R2717 VDD.n354 VDD.n268 0.0741842
R2718 VDD.n357 VDD.n268 0.0705
R2719 VDD.n525 VDD.n267 0.0705
R2720 VDD.n501 VDD.n500 0.0605
R2721 VDD.n463 VDD.n462 0.0605
R2722 VDD.n314 VDD.n313 0.0605
R2723 VDD.n342 VDD.n341 0.0605
R2724 VDD.n223 VDD.n113 0.0505
R2725 VDD.n223 VDD.n29 0.0331316
R2726 VDD.n28 VDD.n27 0.0325
R2727 VDD.n440 VDD.n268 0.0305
R2728 VDD.n525 VDD.n441 0.0305
R2729 VDD VDD.n571 0.0205
R2730 VDD.n488 VDD.n486 0.0155
R2731 VDD.n327 VDD.n291 0.0155
R2732 VSS.n930 VSS.n929 126010
R2733 VSS.n774 VSS.t385 48139.4
R2734 VSS.n775 VSS.n774 47272.7
R2735 VSS.n930 VSS.n74 10702.8
R2736 VSS.n929 VSS.n928 7793.96
R2737 VSS.n212 VSS.n207 5590
R2738 VSS.n414 VSS.n362 4239.13
R2739 VSS.t487 VSS.t383 3033.33
R2740 VSS.n748 VSS.n177 3018.12
R2741 VSS.n818 VSS.n817 2140.84
R2742 VSS.t383 VSS.t481 1733.33
R2743 VSS.n668 VSS.n231 1618.73
R2744 VSS.n669 VSS.t487 1462.5
R2745 VSS.t481 VSS.t117 1300
R2746 VSS.n119 VSS.n105 1266.62
R2747 VSS.n212 VSS.t385 996.668
R2748 VSS.t491 VSS.t82 878.379
R2749 VSS.n776 VSS.n119 780
R2750 VSS.n145 VSS.n122 780
R2751 VSS.n121 VSS.n120 780
R2752 VSS.n773 VSS.n122 715
R2753 VSS.n669 VSS.n207 617.5
R2754 VSS.n776 VSS.n775 507
R2755 VSS.t82 VSS.t484 501.932
R2756 VSS.n952 VSS.n951 500
R2757 VSS.n60 VSS.n59 500
R2758 VSS.n59 VSS.n54 500
R2759 VSS.n988 VSS.n8 500
R2760 VSS.n669 VSS.t491 423.505
R2761 VSS.n177 VSS.n145 401.685
R2762 VSS.t325 VSS.n969 380
R2763 VSS.n973 VSS.t186 380
R2764 VSS.t484 VSS.t411 376.449
R2765 VSS.t412 VSS.n71 360
R2766 VSS.n982 VSS.t92 360
R2767 VSS.t115 VSS.n773 330.079
R2768 VSS.t49 VSS.t63 320
R2769 VSS.t246 VSS.t266 320
R2770 VSS.n797 VSS.n793 296.139
R2771 VSS.n796 VSS.n795 296.139
R2772 VSS.n804 VSS.n803 296.139
R2773 VSS.n806 VSS.n805 296.139
R2774 VSS.n809 VSS.n98 296.139
R2775 VSS.n815 VSS.n92 296.139
R2776 VSS.n330 VSS.n239 282.61
R2777 VSS.n330 VSS.n251 282.61
R2778 VSS.n283 VSS.n276 282.61
R2779 VSS.n276 VSS.n79 282.61
R2780 VSS.n773 VSS.t43 279.298
R2781 VSS.n775 VSS.n120 273
R2782 VSS.n67 VSS.t51 260
R2783 VSS.n980 VSS.t255 260
R2784 VSS.n958 VSS.t113 240
R2785 VSS.n958 VSS.t386 240
R2786 VSS.n981 VSS.t139 240
R2787 VSS.t87 VSS.n981 240
R2788 VSS.n951 VSS.n950 230
R2789 VSS.n988 VSS.n7 230
R2790 VSS.n311 VSS.n85 226.088
R2791 VSS.n819 VSS.n86 226.088
R2792 VSS.n355 VSS.n354 220.435
R2793 VSS.n230 VSS.n229 204.55
R2794 VSS.n324 VSS.t348 203.478
R2795 VSS.n282 VSS.t374 203.478
R2796 VSS.n324 VSS.t344 192.174
R2797 VSS.t334 VSS.n282 192.174
R2798 VSS.n669 VSS.n668 178.814
R2799 VSS.n407 VSS.n406 169.565
R2800 VSS.n740 VSS.n739 164.142
R2801 VSS.n740 VSS.n183 164.142
R2802 VSS.n790 VSS.n105 163.127
R2803 VSS.n969 VSS.t506 160
R2804 VSS.t2 VSS.n973 160
R2805 VSS.n317 VSS.t11 158.262
R2806 VSS.t336 VSS.t167 146.958
R2807 VSS.n304 VSS.t403 146.958
R2808 VSS.t367 VSS.t342 146.958
R2809 VSS.n71 VSS.t109 140
R2810 VSS.t392 VSS.n67 140
R2811 VSS.t133 VSS.n980 140
R2812 VSS.n982 VSS.t89 140
R2813 VSS.n756 VSS.n755 131.314
R2814 VSS.n759 VSS.n758 131.314
R2815 VSS.n354 VSS.n239 130
R2816 VSS.n928 VSS.n79 130
R2817 VSS.n416 VSS.n415 121.016
R2818 VSS.t257 VSS.t41 120.001
R2819 VSS.t169 VSS.n746 118.183
R2820 VSS.n231 VSS.n230 116.713
R2821 VSS.n746 VSS.t129 111.617
R2822 VSS.n362 VSS.t72 110.001
R2823 VSS.n791 VSS.n790 107.915
R2824 VSS.n793 VSS.n792 107.915
R2825 VSS.n795 VSS.n794 107.915
R2826 VSS.n803 VSS.n99 107.915
R2827 VSS.n807 VSS.n806 107.915
R2828 VSS.n809 VSS.n808 107.915
R2829 VSS.n229 VSS.n228 107.915
R2830 VSS.n310 VSS.t9 101.74
R2831 VSS.n677 VSS.n194 92.6738
R2832 VSS.n382 VSS.n194 92.6738
R2833 VSS.n765 VSS.t123 91.9197
R2834 VSS.n230 VSS.n227 91.1502
R2835 VSS.n773 VSS.n772 90.2783
R2836 VSS.n741 VSS.n182 87.5005
R2837 VSS.n741 VSS.n180 87.5005
R2838 VSS.n745 VSS.n180 87.5005
R2839 VSS.n745 VSS.n143 87.5005
R2840 VSS.n750 VSS.n143 87.5005
R2841 VSS.n750 VSS.n140 87.5005
R2842 VSS.n754 VSS.n140 87.5005
R2843 VSS.n754 VSS.n139 87.5005
R2844 VSS.n696 VSS.n139 87.5005
R2845 VSS.n696 VSS.n135 87.5005
R2846 VSS.n760 VSS.n135 87.5005
R2847 VSS.n760 VSS.n132 87.5005
R2848 VSS.n764 VSS.n132 87.5005
R2849 VSS.n764 VSS.n131 87.5005
R2850 VSS.n682 VSS.n131 87.5005
R2851 VSS.n682 VSS.n191 87.5005
R2852 VSS.n678 VSS.n191 87.5005
R2853 VSS.n678 VSS.n193 87.5005
R2854 VSS.n388 VSS.n387 87.5005
R2855 VSS.n390 VSS.n373 87.5005
R2856 VSS.n393 VSS.n373 87.5005
R2857 VSS.n397 VSS.n396 87.5005
R2858 VSS.n399 VSS.n375 87.5005
R2859 VSS.n738 VSS.n184 87.5005
R2860 VSS.n707 VSS.n184 87.5005
R2861 VSS.n707 VSS.n179 87.5005
R2862 VSS.n179 VSS.n178 87.5005
R2863 VSS.n178 VSS.n144 87.5005
R2864 VSS.n702 VSS.n144 87.5005
R2865 VSS.n702 VSS.n138 87.5005
R2866 VSS.n698 VSS.n138 87.5005
R2867 VSS.n698 VSS.n187 87.5005
R2868 VSS.n694 VSS.n187 87.5005
R2869 VSS.n694 VSS.n136 87.5005
R2870 VSS.n690 VSS.n136 87.5005
R2871 VSS.n690 VSS.n130 87.5005
R2872 VSS.n686 VSS.n130 87.5005
R2873 VSS.n686 VSS.n684 87.5005
R2874 VSS.n684 VSS.n189 87.5005
R2875 VSS.n195 VSS.n189 87.5005
R2876 VSS.n383 VSS.n195 87.5005
R2877 VSS.n733 VSS.n731 87.5005
R2878 VSS.n729 VSS.n711 87.5005
R2879 VSS.n725 VSS.n723 87.5005
R2880 VSS.n721 VSS.n713 87.5005
R2881 VSS.n16 VSS.n15 87.5005
R2882 VSS.n20 VSS.n19 87.5005
R2883 VSS.n22 VSS.n20 87.5005
R2884 VSS.n73 VSS.n72 87.5005
R2885 VSS.n72 VSS.n66 87.5005
R2886 VSS.n959 VSS.n66 87.5005
R2887 VSS.n959 VSS.n42 87.5005
R2888 VSS.n963 VSS.n42 87.5005
R2889 VSS.n963 VSS.n41 87.5005
R2890 VSS.n41 VSS.n35 87.5005
R2891 VSS.n61 VSS.n35 87.5005
R2892 VSS.n61 VSS.n44 87.5005
R2893 VSS.n53 VSS.n44 87.5005
R2894 VSS.n53 VSS.n34 87.5005
R2895 VSS.n34 VSS.n33 87.5005
R2896 VSS.n48 VSS.n33 87.5005
R2897 VSS.n48 VSS.n29 87.5005
R2898 VSS.n29 VSS.n28 87.5005
R2899 VSS.n28 VSS.n27 87.5005
R2900 VSS.n27 VSS.n6 87.5005
R2901 VSS.n989 VSS.n6 87.5005
R2902 VSS.n941 VSS.n940 87.5005
R2903 VSS.n945 VSS.n944 87.5005
R2904 VSS.n953 VSS.n70 87.5005
R2905 VSS.n953 VSS.n68 87.5005
R2906 VSS.n957 VSS.n68 87.5005
R2907 VSS.n957 VSS.n40 87.5005
R2908 VSS.n964 VSS.n40 87.5005
R2909 VSS.n964 VSS.n37 87.5005
R2910 VSS.n968 VSS.n37 87.5005
R2911 VSS.n968 VSS.n36 87.5005
R2912 VSS.n58 VSS.n36 87.5005
R2913 VSS.n58 VSS.n55 87.5005
R2914 VSS.n55 VSS.n32 87.5005
R2915 VSS.n975 VSS.n32 87.5005
R2916 VSS.n975 VSS.n30 87.5005
R2917 VSS.n979 VSS.n30 87.5005
R2918 VSS.n979 VSS.n26 87.5005
R2919 VSS.n983 VSS.n26 87.5005
R2920 VSS.n983 VSS.n10 87.5005
R2921 VSS.n987 VSS.n10 87.5005
R2922 VSS.n329 VSS.n245 87.5005
R2923 VSS.n329 VSS.n252 87.5005
R2924 VSS.n325 VSS.n252 87.5005
R2925 VSS.n325 VSS.n254 87.5005
R2926 VSS.n316 VSS.n254 87.5005
R2927 VSS.n316 VSS.n259 87.5005
R2928 VSS.n312 VSS.n259 87.5005
R2929 VSS.n312 VSS.n261 87.5005
R2930 VSS.n303 VSS.n261 87.5005
R2931 VSS.n303 VSS.n265 87.5005
R2932 VSS.n299 VSS.n265 87.5005
R2933 VSS.n299 VSS.n298 87.5005
R2934 VSS.n298 VSS.n267 87.5005
R2935 VSS.n289 VSS.n267 87.5005
R2936 VSS.n289 VSS.n273 87.5005
R2937 VSS.n284 VSS.n273 87.5005
R2938 VSS.n284 VSS.n275 87.5005
R2939 VSS.n275 VSS.n82 87.5005
R2940 VSS.n908 VSS.n80 87.5005
R2941 VSS.n912 VSS.n911 87.5005
R2942 VSS.n916 VSS.n915 87.5005
R2943 VSS.n920 VSS.n919 87.5005
R2944 VSS.n922 VSS.n81 87.5005
R2945 VSS.n332 VSS.n331 87.5005
R2946 VSS.n331 VSS.n249 87.5005
R2947 VSS.n323 VSS.n249 87.5005
R2948 VSS.n323 VSS.n255 87.5005
R2949 VSS.n318 VSS.n255 87.5005
R2950 VSS.n318 VSS.n257 87.5005
R2951 VSS.n309 VSS.n257 87.5005
R2952 VSS.n309 VSS.n262 87.5005
R2953 VSS.n305 VSS.n262 87.5005
R2954 VSS.n305 VSS.n264 87.5005
R2955 VSS.n269 VSS.n264 87.5005
R2956 VSS.n296 VSS.n269 87.5005
R2957 VSS.n296 VSS.n268 87.5005
R2958 VSS.n291 VSS.n268 87.5005
R2959 VSS.n291 VSS.n271 87.5005
R2960 VSS.n281 VSS.n271 87.5005
R2961 VSS.n281 VSS.n278 87.5005
R2962 VSS.n278 VSS.n277 87.5005
R2963 VSS.n337 VSS.n336 87.5005
R2964 VSS.n341 VSS.n340 87.5005
R2965 VSS.n345 VSS.n344 87.5005
R2966 VSS.n349 VSS.n348 87.5005
R2967 VSS.t432 VSS.t198 85.354
R2968 VSS.t234 VSS.n697 85.354
R2969 VSS.n414 VSS.n413 84.7831
R2970 VSS.n60 VSS.t415 80.0005
R2971 VSS.n54 VSS.t188 80.0005
R2972 VSS.n368 VSS.n367 78.8053
R2973 VSS.n767 VSS.n125 77.0005
R2974 VSS.n204 VSS.n202 76.8701
R2975 VSS.n739 VSS.n74 75.5056
R2976 VSS.n766 VSS.n129 75.5056
R2977 VSS.n359 VSS.n355 73.4788
R2978 VSS.n683 VSS.n190 72.2227
R2979 VSS.n227 VSS.n210 68.2505
R2980 VSS.n384 VSS.n383 68.2505
R2981 VSS.n738 VSS.n185 68.2505
R2982 VSS.n989 VSS.n5 68.2505
R2983 VSS.n937 VSS.n73 68.2505
R2984 VSS.n277 VSS.n80 68.2505
R2985 VSS.n333 VSS.n332 68.2505
R2986 VSS.n406 VSS.n405 67.8266
R2987 VSS.n773 VSS.n121 65.0005
R2988 VSS.n367 VSS.n363 64.4943
R2989 VSS.n202 VSS.n196 64.4129
R2990 VSS.n816 VSS.n91 60.8596
R2991 VSS.n952 VSS.t156 60.0005
R2992 VSS.t94 VSS.n8 60.0005
R2993 VSS.n159 VSS.n158 59.5005
R2994 VSS.n671 VSS.n201 59.5005
R2995 VSS.n421 VSS.n356 59.5005
R2996 VSS.n689 VSS.t203 59.0914
R2997 VSS.n317 VSS.t336 56.5222
R2998 VSS.t342 VSS.n272 56.5222
R2999 VSS.n791 VSS.t354 55.2129
R3000 VSS.n792 VSS.t371 55.2129
R3001 VSS.t327 VSS.n797 55.2129
R3002 VSS.n796 VSS.t359 55.2129
R3003 VSS.n794 VSS.t365 55.2129
R3004 VSS.t366 VSS.n99 55.2129
R3005 VSS.n804 VSS.t200 55.2129
R3006 VSS.n805 VSS.t215 55.2129
R3007 VSS.n807 VSS.t164 55.2129
R3008 VSS.n808 VSS.t210 55.2129
R3009 VSS.n98 VSS.t360 55.2129
R3010 VSS.t214 VSS.n92 55.2129
R3011 VSS.t211 VSS.n91 55.2129
R3012 VSS.n228 VSS.t216 55.2129
R3013 VSS.n789 VSS.n104 52.5005
R3014 VSS.n798 VSS.n104 52.5005
R3015 VSS.n798 VSS.n101 52.5005
R3016 VSS.n802 VSS.n101 52.5005
R3017 VSS.n802 VSS.n100 52.5005
R3018 VSS.n100 VSS.n97 52.5005
R3019 VSS.n810 VSS.n97 52.5005
R3020 VSS.n810 VSS.n94 52.5005
R3021 VSS.n814 VSS.n94 52.5005
R3022 VSS.n814 VSS.n93 52.5005
R3023 VSS.n227 VSS.n93 52.5005
R3024 VSS.n158 VSS.n157 52.5005
R3025 VSS.n157 VSS.n154 52.5005
R3026 VSS.n154 VSS.n118 52.5005
R3027 VSS.n777 VSS.n118 52.5005
R3028 VSS.n777 VSS.n116 52.5005
R3029 VSS.n781 VSS.n116 52.5005
R3030 VSS.n784 VSS.n783 52.5005
R3031 VSS.n163 VSS.n162 52.5005
R3032 VSS.n167 VSS.n166 52.5005
R3033 VSS.n171 VSS.n170 52.5005
R3034 VSS.n175 VSS.n151 52.5005
R3035 VSS.n150 VSS.n128 52.5005
R3036 VSS.n767 VSS.n128 52.5005
R3037 VSS.n771 VSS.n125 52.5005
R3038 VSS.n771 VSS.n124 52.5005
R3039 VSS.n213 VSS.n124 52.5005
R3040 VSS.n216 VSS.n213 52.5005
R3041 VSS.n219 VSS.n218 52.5005
R3042 VSS.n223 VSS.n222 52.5005
R3043 VSS.n650 VSS.n649 52.5005
R3044 VSS.n651 VSS.n650 52.5005
R3045 VSS.n655 VSS.n654 52.5005
R3046 VSS.n659 VSS.n658 52.5005
R3047 VSS.n663 VSS.n662 52.5005
R3048 VSS.n637 VSS.n635 52.5005
R3049 VSS.n633 VSS.n615 52.5005
R3050 VSS.n625 VSS.n623 52.5005
R3051 VSS.n621 VSS.n618 52.5005
R3052 VSS.n671 VSS.n198 52.5005
R3053 VSS.n675 VSS.n198 52.5005
R3054 VSS.n675 VSS.n197 52.5005
R3055 VSS.n380 VSS.n197 52.5005
R3056 VSS.n380 VSS.n366 52.5005
R3057 VSS.n408 VSS.n366 52.5005
R3058 VSS.n408 VSS.n364 52.5005
R3059 VSS.n412 VSS.n364 52.5005
R3060 VSS.n412 VSS.n358 52.5005
R3061 VSS.n417 VSS.n358 52.5005
R3062 VSS.n436 VSS.n435 52.5005
R3063 VSS.n432 VSS.n431 52.5005
R3064 VSS.n428 VSS.n427 52.5005
R3065 VSS.n424 VSS.n423 52.5005
R3066 VSS.n774 VSS.t115 50.7817
R3067 VSS.n789 VSS.n106 50.7505
R3068 VSS.n647 VSS.n446 50.7505
R3069 VSS.n667 VSS.n236 50.7505
R3070 VSS.n403 VSS.n193 50.7505
R3071 VSS.n715 VSS.n182 50.7505
R3072 VSS.n949 VSS.n70 50.7505
R3073 VSS.n987 VSS.n9 50.7505
R3074 VSS.n926 VSS.n82 50.7505
R3075 VSS.n353 VSS.n245 50.7505
R3076 VSS.n816 VSS.n815 47.0565
R3077 VSS.t219 VSS.t242 45.2179
R3078 VSS.n949 VSS.n934 43.7505
R3079 VSS.t156 VSS.t4 40.0005
R3080 VSS.t4 VSS.t412 40.0005
R3081 VSS.t109 VSS.t111 40.0005
R3082 VSS.t111 VSS.t107 40.0005
R3083 VSS.t107 VSS.t113 40.0005
R3084 VSS.t386 VSS.t388 40.0005
R3085 VSS.t388 VSS.t390 40.0005
R3086 VSS.t390 VSS.t392 40.0005
R3087 VSS.t51 VSS.t53 40.0005
R3088 VSS.t53 VSS.t33 40.0005
R3089 VSS.t33 VSS.t56 40.0005
R3090 VSS.t56 VSS.t58 40.0005
R3091 VSS.t58 VSS.t34 40.0005
R3092 VSS.t61 VSS.t34 40.0005
R3093 VSS.t61 VSS.t63 40.0005
R3094 VSS.t65 VSS.t49 40.0005
R3095 VSS.t30 VSS.t65 40.0005
R3096 VSS.t29 VSS.t30 40.0005
R3097 VSS.t16 VSS.t17 40.0005
R3098 VSS.t70 VSS.t16 40.0005
R3099 VSS.t72 VSS.t70 40.0005
R3100 VSS.t18 VSS.t504 40.0005
R3101 VSS.t504 VSS.t506 40.0005
R3102 VSS.t158 VSS.t2 40.0005
R3103 VSS.t41 VSS.t158 40.0005
R3104 VSS.t259 VSS.t257 40.0005
R3105 VSS.t83 VSS.t259 40.0005
R3106 VSS.t37 VSS.t83 40.0005
R3107 VSS.t23 VSS.t35 40.0005
R3108 VSS.t264 VSS.t23 40.0005
R3109 VSS.t266 VSS.t264 40.0005
R3110 VSS.t248 VSS.t246 40.0005
R3111 VSS.t248 VSS.t154 40.0005
R3112 VSS.t154 VSS.t152 40.0005
R3113 VSS.t152 VSS.t150 40.0005
R3114 VSS.t150 VSS.t190 40.0005
R3115 VSS.t190 VSS.t253 40.0005
R3116 VSS.t253 VSS.t255 40.0005
R3117 VSS.t135 VSS.t133 40.0005
R3118 VSS.t137 VSS.t135 40.0005
R3119 VSS.t139 VSS.t137 40.0005
R3120 VSS.t84 VSS.t87 40.0005
R3121 VSS.t39 VSS.t84 40.0005
R3122 VSS.t89 VSS.t39 40.0005
R3123 VSS.t92 VSS.t0 40.0005
R3124 VSS.t0 VSS.t94 40.0005
R3125 VSS.n415 VSS.n414 36.2334
R3126 VSS.n667 VSS.n237 35.0005
R3127 VSS.n417 VSS.n356 35.0005
R3128 VSS.t235 VSS.n85 33.9135
R3129 VSS.t127 VSS.n765 32.8288
R3130 VSS.n819 VSS.n818 31.0875
R3131 VSS.n820 VSS.n85 29.6637
R3132 VSS.n971 VSS.n970 29.6637
R3133 VSS.n758 VSS.n757 29.6637
R3134 VSS.n748 VSS.t432 28.7252
R3135 VSS.n820 VSS.n819 28.4005
R3136 VSS.n972 VSS.n971 28.4005
R3137 VSS.n757 VSS.n756 28.4005
R3138 VSS.n677 VSS.n676 28.2614
R3139 VSS.n382 VSS.n381 28.2614
R3140 VSS.n645 VSS.n613 27.8548
R3141 VSS.t105 VSS.t395 26.2631
R3142 VSS.n717 VSS.n715 26.2505
R3143 VSS.n353 VSS.n246 26.2505
R3144 VSS.t354 VSS.t141 25.097
R3145 VSS.t141 VSS.t371 25.097
R3146 VSS.t322 VSS.t327 25.097
R3147 VSS.t322 VSS.t359 25.097
R3148 VSS.t365 VSS.t321 25.097
R3149 VSS.t321 VSS.t366 25.097
R3150 VSS.t243 VSS.t200 25.097
R3151 VSS.t243 VSS.t215 25.097
R3152 VSS.t164 VSS.t96 25.097
R3153 VSS.t96 VSS.t210 25.097
R3154 VSS.t360 VSS.t116 25.097
R3155 VSS.t116 VSS.t214 25.097
R3156 VSS.t382 VSS.t211 25.097
R3157 VSS.t216 VSS.t382 25.097
R3158 VSS.n486 VSS.n485 24.6095
R3159 VSS.n488 VSS.n487 24.6095
R3160 VSS.n196 VSS.t180 24.3168
R3161 VSS.t131 VSS.n194 24.3168
R3162 VSS.n363 VSS.t77 24.2761
R3163 VSS.n415 VSS.t182 24.2761
R3164 VSS.n532 VSS.t433 23.9124
R3165 VSS.n893 VSS.t343 23.9124
R3166 VSS.n569 VSS.t128 23.8177
R3167 VSS.n864 VSS.t337 23.8177
R3168 VSS.n535 VSS.n534 23.8024
R3169 VSS.n841 VSS.n840 23.8024
R3170 VSS.n555 VSS.n554 23.7551
R3171 VSS.n850 VSS.n849 23.7551
R3172 VSS.t430 VSS.n669 22.6092
R3173 VSS.n203 VSS.t424 22.6092
R3174 VSS.t340 VSS.n251 22.6092
R3175 VSS.t338 VSS.t340 22.6092
R3176 VSS.t346 VSS.t338 22.6092
R3177 VSS.t344 VSS.t346 22.6092
R3178 VSS.t378 VSS.t348 22.6092
R3179 VSS.t376 VSS.t378 22.6092
R3180 VSS.t165 VSS.t376 22.6092
R3181 VSS.t417 VSS.t206 22.6092
R3182 VSS.t191 VSS.t417 22.6092
R3183 VSS.t167 VSS.t191 22.6092
R3184 VSS.t9 VSS.t11 22.6092
R3185 VSS.t502 VSS.t503 22.6092
R3186 VSS.t501 VSS.t502 22.6092
R3187 VSS.t163 VSS.t501 22.6092
R3188 VSS.t162 VSS.t163 22.6092
R3189 VSS.t161 VSS.t162 22.6092
R3190 VSS.t185 VSS.t161 22.6092
R3191 VSS.t184 VSS.t185 22.6092
R3192 VSS.t183 VSS.t184 22.6092
R3193 VSS.t22 VSS.t183 22.6092
R3194 VSS.t21 VSS.t22 22.6092
R3195 VSS.t20 VSS.t21 22.6092
R3196 VSS.t236 VSS.t235 22.6092
R3197 VSS.t237 VSS.t236 22.6092
R3198 VSS.t238 VSS.t237 22.6092
R3199 VSS.t239 VSS.t238 22.6092
R3200 VSS.t240 VSS.t239 22.6092
R3201 VSS.t241 VSS.t240 22.6092
R3202 VSS.t242 VSS.t241 22.6092
R3203 VSS.t217 VSS.t219 22.6092
R3204 VSS.t221 VSS.t217 22.6092
R3205 VSS.t223 VSS.t221 22.6092
R3206 VSS.t225 VSS.t223 22.6092
R3207 VSS.t404 VSS.t403 22.6092
R3208 VSS.t405 VSS.t404 22.6092
R3209 VSS.t406 VSS.t405 22.6092
R3210 VSS.t407 VSS.t406 22.6092
R3211 VSS.t408 VSS.t407 22.6092
R3212 VSS.t409 VSS.t408 22.6092
R3213 VSS.t409 VSS.t410 22.6092
R3214 VSS.t294 VSS.t292 22.6092
R3215 VSS.t296 VSS.t294 22.6092
R3216 VSS.t298 VSS.t296 22.6092
R3217 VSS.t80 VSS.t298 22.6092
R3218 VSS.t78 VSS.t80 22.6092
R3219 VSS.t310 VSS.t78 22.6092
R3220 VSS.t312 VSS.t310 22.6092
R3221 VSS.t306 VSS.t312 22.6092
R3222 VSS.t302 VSS.t306 22.6092
R3223 VSS.t304 VSS.t302 22.6092
R3224 VSS.t300 VSS.t304 22.6092
R3225 VSS.n272 VSS.t300 22.6092
R3226 VSS.t369 VSS.t367 22.6092
R3227 VSS.t372 VSS.t369 22.6092
R3228 VSS.t363 VSS.t372 22.6092
R3229 VSS.t357 VSS.t355 22.6092
R3230 VSS.t350 VSS.t357 22.6092
R3231 VSS.t374 VSS.t350 22.6092
R3232 VSS.t332 VSS.t334 22.6092
R3233 VSS.t330 VSS.t332 22.6092
R3234 VSS.t318 VSS.t330 22.6092
R3235 VSS.n283 VSS.t318 22.6092
R3236 VSS.n381 VSS.n371 22.2836
R3237 VSS.n407 VSS.n368 22.2836
R3238 VSS.n416 VSS.n360 22.2836
R3239 VSS.n360 VSS.n359 22.2836
R3240 VSS.n736 VSS.n137 21.0437
R3241 VSS.n906 VSS.n905 21.0437
R3242 VSS.n950 VSS.n930 20.0005
R3243 VSS.n361 VSS.t29 20.0005
R3244 VSS.t17 VSS.n361 20.0005
R3245 VSS.n970 VSS.t325 20.0005
R3246 VSS.n970 VSS.t415 20.0005
R3247 VSS.n972 VSS.t188 20.0005
R3248 VSS.t186 VSS.n972 20.0005
R3249 VSS.n974 VSS.t37 20.0005
R3250 VSS.n974 VSS.t35 20.0005
R3251 VSS.n929 VSS.n7 20.0005
R3252 VSS.n756 VSS.t227 19.6975
R3253 VSS.n758 VSS.t402 19.6975
R3254 VSS.n787 VSS.n113 19.4846
R3255 VSS.n205 VSS.t426 19.2179
R3256 VSS.n559 VSS.n558 18.5679
R3257 VSS.n854 VSS.n853 18.5679
R3258 VSS.n449 VSS.n448 18.5483
R3259 VSS.n526 VSS.n525 18.5483
R3260 VSS.n825 VSS.n822 18.2754
R3261 VSS.n863 VSS.n862 18.2754
R3262 VSS.n568 VSS.n567 18.2754
R3263 VSS.n605 VSS.n604 18.2754
R3264 VSS.n565 VSS.n560 18.157
R3265 VSS.n602 VSS.n597 18.157
R3266 VSS.n530 VSS.n529 18.157
R3267 VSS.n902 VSS.n901 18.157
R3268 VSS.n831 VSS.n830 18.157
R3269 VSS.n860 VSS.n855 18.157
R3270 VSS.n371 VSS.t508 17.1206
R3271 VSS.n368 VSS.t394 17.1206
R3272 VSS.n360 VSS.t205 17.1206
R3273 VSS.n670 VSS.t428 16.957
R3274 VSS.t181 VSS.t426 16.957
R3275 VSS.t503 VSS.n310 16.957
R3276 VSS.n311 VSS.t20 16.957
R3277 VSS.t146 VSS.n86 16.957
R3278 VSS.t145 VSS.t270 16.957
R3279 VSS.t144 VSS.t272 16.957
R3280 VSS.t8 VSS.t274 16.957
R3281 VSS.t7 VSS.t276 16.957
R3282 VSS.t6 VSS.t268 16.957
R3283 VSS.t47 VSS.t278 16.957
R3284 VSS.t46 VSS.t280 16.957
R3285 VSS.t45 VSS.t284 16.957
R3286 VSS.t76 VSS.t286 16.957
R3287 VSS.t75 VSS.t288 16.957
R3288 VSS.t74 VSS.t290 16.957
R3289 VSS.n683 VSS.n123 16.4146
R3290 VSS.n669 VSS.n206 16.4146
R3291 VSS.n501 VSS.n490 15.2627
R3292 VSS.n459 VSS.n458 15.2222
R3293 VSS.n517 VSS.n516 15.2222
R3294 VSS.n107 VSS.t44 15.202
R3295 VSS.n994 VSS.n993 15.143
R3296 VSS.n817 VSS.n816 15.1168
R3297 VSS.n107 VSS.t323 14.302
R3298 VSS.n108 VSS.t324 14.302
R3299 VSS.n109 VSS.t142 14.302
R3300 VSS.n110 VSS.t132 14.302
R3301 VSS.n111 VSS.t143 14.302
R3302 VSS.n112 VSS.t384 14.302
R3303 VSS.n454 VSS.n450 13.793
R3304 VSS.n522 VSS.n518 13.793
R3305 VSS.n992 VSS.n991 13.5005
R3306 VSS.n463 VSS.n460 13.2657
R3307 VSS.n506 VSS.n503 13.2657
R3308 VSS.n183 VSS.t380 13.1318
R3309 VSS.t380 VSS.t178 13.1318
R3310 VSS.t178 VSS.t176 13.1318
R3311 VSS.t176 VSS.t129 13.1318
R3312 VSS.t212 VSS.t169 13.1318
R3313 VSS.t361 VSS.t212 13.1318
R3314 VSS.t125 VSS.t361 13.1318
R3315 VSS.t174 VSS.t196 13.1318
R3316 VSS.t328 VSS.t174 13.1318
R3317 VSS.t198 VSS.t328 13.1318
R3318 VSS.n749 VSS.t435 13.1318
R3319 VSS.t441 VSS.t435 13.1318
R3320 VSS.t443 VSS.t441 13.1318
R3321 VSS.t445 VSS.t443 13.1318
R3322 VSS.t447 VSS.t445 13.1318
R3323 VSS.t439 VSS.t447 13.1318
R3324 VSS.t27 VSS.t439 13.1318
R3325 VSS.t25 VSS.t27 13.1318
R3326 VSS.t437 VSS.t25 13.1318
R3327 VSS.t451 VSS.t437 13.1318
R3328 VSS.t453 VSS.t451 13.1318
R3329 VSS.t459 VSS.t453 13.1318
R3330 VSS.t228 VSS.t227 13.1318
R3331 VSS.t228 VSS.t229 13.1318
R3332 VSS.t229 VSS.t230 13.1318
R3333 VSS.t230 VSS.t231 13.1318
R3334 VSS.t231 VSS.t232 13.1318
R3335 VSS.t232 VSS.t233 13.1318
R3336 VSS.t233 VSS.t234 13.1318
R3337 VSS.t99 VSS.t97 13.1318
R3338 VSS.t97 VSS.t101 13.1318
R3339 VSS.t101 VSS.t103 13.1318
R3340 VSS.t103 VSS.t105 13.1318
R3341 VSS.t395 VSS.t396 13.1318
R3342 VSS.t396 VSS.t397 13.1318
R3343 VSS.t397 VSS.t398 13.1318
R3344 VSS.t398 VSS.t399 13.1318
R3345 VSS.t399 VSS.t400 13.1318
R3346 VSS.t400 VSS.t401 13.1318
R3347 VSS.t401 VSS.t402 13.1318
R3348 VSS.t15 VSS.t24 13.1318
R3349 VSS.t14 VSS.t15 13.1318
R3350 VSS.t13 VSS.t14 13.1318
R3351 VSS.t120 VSS.t13 13.1318
R3352 VSS.t119 VSS.t120 13.1318
R3353 VSS.t118 VSS.t119 13.1318
R3354 VSS.t149 VSS.t118 13.1318
R3355 VSS.t148 VSS.t149 13.1318
R3356 VSS.t147 VSS.t148 13.1318
R3357 VSS.t32 VSS.t147 13.1318
R3358 VSS.t31 VSS.t32 13.1318
R3359 VSS.t203 VSS.t123 13.1318
R3360 VSS.t499 VSS.t316 13.1318
R3361 VSS.t511 VSS.t499 13.1318
R3362 VSS.t201 VSS.t511 13.1318
R3363 VSS.t509 VSS.t352 13.1318
R3364 VSS.t352 VSS.t208 13.1318
R3365 VSS.t208 VSS.t419 13.1318
R3366 VSS.n469 VSS.n461 12.9149
R3367 VSS.n512 VSS.n504 12.9149
R3368 VSS.n493 VSS.n492 12.4151
R3369 VSS.n552 VSS.n551 11.7005
R3370 VSS.n581 VSS.n580 11.7005
R3371 VSS.n592 VSS.n591 11.7005
R3372 VSS.n892 VSS.n891 11.7005
R3373 VSS.n888 VSS.n875 11.7005
R3374 VSS.n848 VSS.n847 11.7005
R3375 VSS.n258 VSS.t165 11.3048
R3376 VSS.t206 VSS.n258 11.3048
R3377 VSS.n304 VSS.t225 11.3048
R3378 VSS.n297 VSS.t282 11.3048
R3379 VSS.n297 VSS.t292 11.3048
R3380 VSS.n290 VSS.t363 11.3048
R3381 VSS.n290 VSS.t355 11.3048
R3382 VSS.n477 VSS.n471 11.0126
R3383 VSS.n405 VSS.n371 10.9792
R3384 VSS.n455 VSS.n454 10.7222
R3385 VSS.n523 VSS.n522 10.7222
R3386 VSS.n362 VSS.t18 10.0005
R3387 VSS.n475 VSS.n474 9.98011
R3388 VSS.t122 VSS.t463 9.84898
R3389 VSS.t121 VSS.t457 9.84898
R3390 VSS.t423 VSS.t465 9.84898
R3391 VSS.t422 VSS.t467 9.84898
R3392 VSS.t421 VSS.t455 9.84898
R3393 VSS.t173 VSS.t469 9.84898
R3394 VSS.t172 VSS.t473 9.84898
R3395 VSS.t171 VSS.t475 9.84898
R3396 VSS.t195 VSS.t477 9.84898
R3397 VSS.t194 VSS.t479 9.84898
R3398 VSS.t193 VSS.t471 9.84898
R3399 VSS.n755 VSS.t91 9.84898
R3400 VSS.n759 VSS.t24 9.84898
R3401 VSS.n689 VSS.t31 9.84898
R3402 VSS.n206 VSS.n190 9.84898
R3403 VSS.n470 VSS.n469 8.76572
R3404 VSS.n513 VSS.n512 8.76572
R3405 VSS.n773 VSS.n123 8.20757
R3406 VSS.n413 VSS.n363 7.97252
R3407 VSS.n204 VSS.n203 7.91354
R3408 VSS.n676 VSS.n196 7.8912
R3409 VSS.n475 VSS.n473 7.51148
R3410 VSS.n971 VSS.n2 6.8599
R3411 VSS.n612 VSS.n526 6.746
R3412 VSS.n640 VSS.t493 6.57557
R3413 VSS.n747 VSS.t125 6.56616
R3414 VSS.t196 VSS.n747 6.56616
R3415 VSS.n701 VSS.t459 6.56616
R3416 VSS.n701 VSS.t461 6.56616
R3417 VSS.n697 VSS.t99 6.56616
R3418 VSS.n766 VSS.t127 6.56616
R3419 VSS.n685 VSS.t201 6.56616
R3420 VSS.n685 VSS.t509 6.56616
R3421 VSS.n629 VSS.n627 6.49615
R3422 VSS.n441 VSS.t498 6.45713
R3423 VSS.n484 VSS.n483 6.41789
R3424 VSS.n502 VSS.n501 6.41789
R3425 VSS.n493 VSS.n489 6.41789
R3426 VSS.n440 VSS.n439 6.41078
R3427 VSS.n629 VSS.n628 6.31615
R3428 VSS.n640 VSS.n639 6.29483
R3429 VSS.n440 VSS.n438 6.29483
R3430 VSS.n642 VSS.n641 6.29333
R3431 VSS.n630 VSS.n629 6.278
R3432 VSS.n551 VSS.t100 5.78141
R3433 VSS.n847 VSS.t226 5.78141
R3434 VSS.n492 VSS.t507 5.7796
R3435 VSS.n550 VSS.n548 5.66497
R3436 VSS.n538 VSS.n536 5.66497
R3437 VSS.n586 VSS.n584 5.66497
R3438 VSS.n835 VSS.n833 5.66497
R3439 VSS.n878 VSS.n876 5.66497
R3440 VSS.n846 VSS.n844 5.66497
R3441 VSS.n643 VSS.n642 5.6555
R3442 VSS.n670 VSS.t430 5.65267
R3443 VSS.t424 VSS.t181 5.65267
R3444 VSS.t270 VSS.t146 5.65267
R3445 VSS.t272 VSS.t145 5.65267
R3446 VSS.t274 VSS.t144 5.65267
R3447 VSS.t276 VSS.t8 5.65267
R3448 VSS.t268 VSS.t7 5.65267
R3449 VSS.t278 VSS.t6 5.65267
R3450 VSS.t280 VSS.t47 5.65267
R3451 VSS.t284 VSS.t46 5.65267
R3452 VSS.t286 VSS.t45 5.65267
R3453 VSS.t288 VSS.t76 5.65267
R3454 VSS.t290 VSS.t75 5.65267
R3455 VSS.t282 VSS.t74 5.65267
R3456 VSS.n448 VSS.t95 5.63749
R3457 VSS.n525 VSS.t413 5.63749
R3458 VSS.n442 VSS.n441 5.5955
R3459 VSS.n473 VSS.t42 5.59012
R3460 VSS.n558 VSS.n556 5.57485
R3461 VSS.n563 VSS.n561 5.57485
R3462 VSS.n600 VSS.n598 5.57485
R3463 VSS.n529 VSS.n527 5.57485
R3464 VSS.n901 VSS.n900 5.57485
R3465 VSS.n828 VSS.n826 5.57485
R3466 VSS.n858 VSS.n856 5.57485
R3467 VSS.n853 VSS.n852 5.57485
R3468 VSS.n466 VSS.n464 5.57485
R3469 VSS.n473 VSS.n472 5.57485
R3470 VSS.n480 VSS.n478 5.57485
R3471 VSS.n458 VSS.n457 5.57485
R3472 VSS.n453 VSS.n452 5.57485
R3473 VSS.n509 VSS.n507 5.57485
R3474 VSS.n499 VSS.n497 5.57485
R3475 VSS.n516 VSS.n515 5.57485
R3476 VSS.n521 VSS.n520 5.57485
R3477 VSS.n448 VSS.n447 5.52748
R3478 VSS.n525 VSS.n524 5.52748
R3479 VSS.n550 VSS.n549 5.4755
R3480 VSS.n538 VSS.n537 5.4755
R3481 VSS.n540 VSS.n539 5.4755
R3482 VSS.n542 VSS.n541 5.4755
R3483 VSS.n544 VSS.n543 5.4755
R3484 VSS.n546 VSS.n545 5.4755
R3485 VSS.n581 VSS.n547 5.4755
R3486 VSS.n583 VSS.n582 5.4755
R3487 VSS.n590 VSS.n589 5.4755
R3488 VSS.n588 VSS.n587 5.4755
R3489 VSS.n586 VSS.n585 5.4755
R3490 VSS.n835 VSS.n834 5.4755
R3491 VSS.n837 VSS.n836 5.4755
R3492 VSS.n839 VSS.n838 5.4755
R3493 VSS.n890 VSS.n889 5.4755
R3494 VSS.n888 VSS.n887 5.4755
R3495 VSS.n886 VSS.n885 5.4755
R3496 VSS.n884 VSS.n883 5.4755
R3497 VSS.n882 VSS.n881 5.4755
R3498 VSS.n880 VSS.n879 5.4755
R3499 VSS.n878 VSS.n877 5.4755
R3500 VSS.n846 VSS.n845 5.4755
R3501 VSS.n558 VSS.n557 5.38537
R3502 VSS.n563 VSS.n562 5.38537
R3503 VSS.n565 VSS.n564 5.38537
R3504 VSS.n567 VSS.n566 5.38537
R3505 VSS.n600 VSS.n599 5.38537
R3506 VSS.n602 VSS.n601 5.38537
R3507 VSS.n604 VSS.n603 5.38537
R3508 VSS.n529 VSS.n528 5.38537
R3509 VSS.n901 VSS.n899 5.38537
R3510 VSS.n825 VSS.n824 5.38537
R3511 VSS.n830 VSS.n829 5.38537
R3512 VSS.n828 VSS.n827 5.38537
R3513 VSS.n862 VSS.n861 5.38537
R3514 VSS.n860 VSS.n859 5.38537
R3515 VSS.n858 VSS.n857 5.38537
R3516 VSS.n853 VSS.n851 5.38537
R3517 VSS.n463 VSS.n462 5.38537
R3518 VSS.n468 VSS.n467 5.38537
R3519 VSS.n466 VSS.n465 5.38537
R3520 VSS.n477 VSS.n476 5.38537
R3521 VSS.n482 VSS.n481 5.38537
R3522 VSS.n480 VSS.n479 5.38537
R3523 VSS.n458 VSS.n456 5.38537
R3524 VSS.n453 VSS.n451 5.38537
R3525 VSS.n506 VSS.n505 5.38537
R3526 VSS.n511 VSS.n510 5.38537
R3527 VSS.n509 VSS.n508 5.38537
R3528 VSS.n495 VSS.n494 5.38537
R3529 VSS.n492 VSS.n491 5.38537
R3530 VSS.n500 VSS.n496 5.38537
R3531 VSS.n499 VSS.n498 5.38537
R3532 VSS.n516 VSS.n514 5.38537
R3533 VSS.n521 VSS.n519 5.38537
R3534 VSS.n483 VSS.n475 5.28311
R3535 VSS.n993 VSS.n992 5.2295
R3536 VSS.n786 VSS.n106 5.2005
R3537 VSS.n785 VSS.n784 5.2005
R3538 VSS.n783 VSS.n114 5.2005
R3539 VSS.n781 VSS.n780 5.2005
R3540 VSS.n119 VSS.n116 5.2005
R3541 VSS.n779 VSS.n116 5.2005
R3542 VSS.n777 VSS.n776 5.2005
R3543 VSS.n778 VSS.n777 5.2005
R3544 VSS.n120 VSS.n118 5.2005
R3545 VSS.n118 VSS.n117 5.2005
R3546 VSS.n154 VSS.n121 5.2005
R3547 VSS.n155 VSS.n154 5.2005
R3548 VSS.n157 VSS.n122 5.2005
R3549 VSS.n157 VSS.n156 5.2005
R3550 VSS.n158 VSS.n145 5.2005
R3551 VSS.n158 VSS.n153 5.2005
R3552 VSS.n767 VSS.n766 5.2005
R3553 VSS.n768 VSS.n767 5.2005
R3554 VSS.n177 VSS.n128 5.2005
R3555 VSS.n128 VSS.n127 5.2005
R3556 VSS.n152 VSS.n150 5.2005
R3557 VSS.n175 VSS.n174 5.2005
R3558 VSS.n173 VSS.n151 5.2005
R3559 VSS.n172 VSS.n171 5.2005
R3560 VSS.n170 VSS.n169 5.2005
R3561 VSS.n168 VSS.n167 5.2005
R3562 VSS.n166 VSS.n165 5.2005
R3563 VSS.n164 VSS.n163 5.2005
R3564 VSS.n162 VSS.n161 5.2005
R3565 VSS.n160 VSS.n159 5.2005
R3566 VSS.n225 VSS.n210 5.2005
R3567 VSS.n224 VSS.n223 5.2005
R3568 VSS.n222 VSS.n221 5.2005
R3569 VSS.n220 VSS.n219 5.2005
R3570 VSS.n218 VSS.n211 5.2005
R3571 VSS.n216 VSS.n215 5.2005
R3572 VSS.n213 VSS.n206 5.2005
R3573 VSS.n214 VSS.n213 5.2005
R3574 VSS.n124 VSS.n123 5.2005
R3575 VSS.n126 VSS.n124 5.2005
R3576 VSS.n772 VSS.n771 5.2005
R3577 VSS.n771 VSS.n770 5.2005
R3578 VSS.n129 VSS.n125 5.2005
R3579 VSS.n769 VSS.n125 5.2005
R3580 VSS.n790 VSS.n789 5.2005
R3581 VSS.n789 VSS.n788 5.2005
R3582 VSS.n793 VSS.n104 5.2005
R3583 VSS.n104 VSS.n103 5.2005
R3584 VSS.n798 VSS.t322 5.2005
R3585 VSS.n799 VSS.n798 5.2005
R3586 VSS.n795 VSS.n101 5.2005
R3587 VSS.n800 VSS.n101 5.2005
R3588 VSS.n803 VSS.n802 5.2005
R3589 VSS.n802 VSS.n801 5.2005
R3590 VSS.n100 VSS.t243 5.2005
R3591 VSS.n102 VSS.n100 5.2005
R3592 VSS.n806 VSS.n97 5.2005
R3593 VSS.n97 VSS.n96 5.2005
R3594 VSS.n810 VSS.n809 5.2005
R3595 VSS.n811 VSS.n810 5.2005
R3596 VSS.t116 VSS.n94 5.2005
R3597 VSS.n812 VSS.n94 5.2005
R3598 VSS.n815 VSS.n814 5.2005
R3599 VSS.n814 VSS.n813 5.2005
R3600 VSS.n229 VSS.n93 5.2005
R3601 VSS.n95 VSS.n93 5.2005
R3602 VSS.n227 VSS.n226 5.2005
R3603 VSS.n668 VSS.n667 5.2005
R3604 VSS.n667 VSS.n666 5.2005
R3605 VSS.n665 VSS.n237 5.2005
R3606 VSS.n664 VSS.n663 5.2005
R3607 VSS.n662 VSS.n661 5.2005
R3608 VSS.n660 VSS.n659 5.2005
R3609 VSS.n658 VSS.n657 5.2005
R3610 VSS.n656 VSS.n655 5.2005
R3611 VSS.n654 VSS.n653 5.2005
R3612 VSS.n652 VSS.n651 5.2005
R3613 VSS.n443 VSS.n236 5.2005
R3614 VSS.n437 VSS.n436 5.2005
R3615 VSS.n435 VSS.n434 5.2005
R3616 VSS.n433 VSS.n432 5.2005
R3617 VSS.n431 VSS.n430 5.2005
R3618 VSS.n429 VSS.n428 5.2005
R3619 VSS.n427 VSS.n426 5.2005
R3620 VSS.n425 VSS.n424 5.2005
R3621 VSS.n383 VSS.n382 5.2005
R3622 VSS.n383 VSS.n378 5.2005
R3623 VSS.n677 VSS.n195 5.2005
R3624 VSS.n377 VSS.n195 5.2005
R3625 VSS.n203 VSS.n189 5.2005
R3626 VSS.n376 VSS.n189 5.2005
R3627 VSS.n385 VSS.n384 5.2005
R3628 VSS.n387 VSS.n386 5.2005
R3629 VSS.n389 VSS.n388 5.2005
R3630 VSS.n391 VSS.n390 5.2005
R3631 VSS.n405 VSS.n373 5.2005
R3632 VSS.n392 VSS.n373 5.2005
R3633 VSS.n394 VSS.n393 5.2005
R3634 VSS.n396 VSS.n395 5.2005
R3635 VSS.n398 VSS.n397 5.2005
R3636 VSS.n400 VSS.n399 5.2005
R3637 VSS.n401 VSS.n375 5.2005
R3638 VSS.n403 VSS.n402 5.2005
R3639 VSS.n382 VSS.n193 5.2005
R3640 VSS.n193 VSS.n192 5.2005
R3641 VSS.n678 VSS.n677 5.2005
R3642 VSS.n679 VSS.n678 5.2005
R3643 VSS.n203 VSS.n191 5.2005
R3644 VSS.n680 VSS.n191 5.2005
R3645 VSS.n277 VSS.n79 5.2005
R3646 VSS.n277 VSS.n84 5.2005
R3647 VSS.n278 VSS.n276 5.2005
R3648 VSS.n279 VSS.n278 5.2005
R3649 VSS.n283 VSS.n281 5.2005
R3650 VSS.n281 VSS.n280 5.2005
R3651 VSS.n282 VSS.n271 5.2005
R3652 VSS.n271 VSS.n270 5.2005
R3653 VSS.n291 VSS.n290 5.2005
R3654 VSS.n292 VSS.n291 5.2005
R3655 VSS.n272 VSS.n268 5.2005
R3656 VSS.n293 VSS.n268 5.2005
R3657 VSS.n297 VSS.n296 5.2005
R3658 VSS.n296 VSS.n295 5.2005
R3659 VSS.n269 VSS.n86 5.2005
R3660 VSS.n294 VSS.n269 5.2005
R3661 VSS.t409 VSS.n264 5.2005
R3662 VSS.n264 VSS.n263 5.2005
R3663 VSS.n305 VSS.n304 5.2005
R3664 VSS.n306 VSS.n305 5.2005
R3665 VSS.t236 VSS.n262 5.2005
R3666 VSS.n307 VSS.n262 5.2005
R3667 VSS.n311 VSS.n309 5.2005
R3668 VSS.n309 VSS.n308 5.2005
R3669 VSS.n310 VSS.n257 5.2005
R3670 VSS.n257 VSS.n256 5.2005
R3671 VSS.n318 VSS.n317 5.2005
R3672 VSS.n319 VSS.n318 5.2005
R3673 VSS.n258 VSS.n255 5.2005
R3674 VSS.n320 VSS.n255 5.2005
R3675 VSS.n324 VSS.n323 5.2005
R3676 VSS.n323 VSS.n322 5.2005
R3677 VSS.n251 VSS.n249 5.2005
R3678 VSS.n321 VSS.n249 5.2005
R3679 VSS.n331 VSS.n330 5.2005
R3680 VSS.n331 VSS.n250 5.2005
R3681 VSS.n332 VSS.n239 5.2005
R3682 VSS.n332 VSS.n248 5.2005
R3683 VSS.n354 VSS.n353 5.2005
R3684 VSS.n353 VSS.n352 5.2005
R3685 VSS.n351 VSS.n246 5.2005
R3686 VSS.n350 VSS.n349 5.2005
R3687 VSS.n348 VSS.n347 5.2005
R3688 VSS.n346 VSS.n345 5.2005
R3689 VSS.n344 VSS.n343 5.2005
R3690 VSS.n342 VSS.n341 5.2005
R3691 VSS.n340 VSS.n339 5.2005
R3692 VSS.n338 VSS.n337 5.2005
R3693 VSS.n336 VSS.n335 5.2005
R3694 VSS.n334 VSS.n333 5.2005
R3695 VSS.n928 VSS.n80 5.2005
R3696 VSS.n907 VSS.n80 5.2005
R3697 VSS.n909 VSS.n908 5.2005
R3698 VSS.n911 VSS.n910 5.2005
R3699 VSS.n913 VSS.n912 5.2005
R3700 VSS.n915 VSS.n914 5.2005
R3701 VSS.n917 VSS.n916 5.2005
R3702 VSS.n919 VSS.n918 5.2005
R3703 VSS.n921 VSS.n920 5.2005
R3704 VSS.n923 VSS.n922 5.2005
R3705 VSS.n924 VSS.n81 5.2005
R3706 VSS.n926 VSS.n925 5.2005
R3707 VSS.n82 VSS.n79 5.2005
R3708 VSS.n83 VSS.n82 5.2005
R3709 VSS.n276 VSS.n275 5.2005
R3710 VSS.n275 VSS.n274 5.2005
R3711 VSS.n284 VSS.n283 5.2005
R3712 VSS.n285 VSS.n284 5.2005
R3713 VSS.n282 VSS.n273 5.2005
R3714 VSS.n286 VSS.n273 5.2005
R3715 VSS.n290 VSS.n289 5.2005
R3716 VSS.n289 VSS.n288 5.2005
R3717 VSS.n272 VSS.n267 5.2005
R3718 VSS.n287 VSS.n267 5.2005
R3719 VSS.n298 VSS.n297 5.2005
R3720 VSS.n298 VSS.n266 5.2005
R3721 VSS.n299 VSS.n86 5.2005
R3722 VSS.n300 VSS.n299 5.2005
R3723 VSS.n265 VSS.t409 5.2005
R3724 VSS.n301 VSS.n265 5.2005
R3725 VSS.n304 VSS.n303 5.2005
R3726 VSS.n303 VSS.n302 5.2005
R3727 VSS.t236 VSS.n261 5.2005
R3728 VSS.n261 VSS.n260 5.2005
R3729 VSS.n312 VSS.n311 5.2005
R3730 VSS.n313 VSS.n312 5.2005
R3731 VSS.n310 VSS.n259 5.2005
R3732 VSS.n314 VSS.n259 5.2005
R3733 VSS.n317 VSS.n316 5.2005
R3734 VSS.n316 VSS.n315 5.2005
R3735 VSS.n258 VSS.n254 5.2005
R3736 VSS.n254 VSS.n253 5.2005
R3737 VSS.n325 VSS.n324 5.2005
R3738 VSS.n326 VSS.n325 5.2005
R3739 VSS.n252 VSS.n251 5.2005
R3740 VSS.n327 VSS.n252 5.2005
R3741 VSS.n330 VSS.n329 5.2005
R3742 VSS.n329 VSS.n328 5.2005
R3743 VSS.n245 VSS.n239 5.2005
R3744 VSS.n247 VSS.n245 5.2005
R3745 VSS.n423 VSS.n238 5.2005
R3746 VSS.n421 VSS.n420 5.2005
R3747 VSS.n359 VSS.n356 5.2005
R3748 VSS.n419 VSS.n356 5.2005
R3749 VSS.n417 VSS.n416 5.2005
R3750 VSS.n418 VSS.n417 5.2005
R3751 VSS.t182 VSS.n358 5.2005
R3752 VSS.n358 VSS.n357 5.2005
R3753 VSS.n413 VSS.n412 5.2005
R3754 VSS.n412 VSS.n411 5.2005
R3755 VSS.n367 VSS.n364 5.2005
R3756 VSS.n410 VSS.n364 5.2005
R3757 VSS.n408 VSS.n407 5.2005
R3758 VSS.n409 VSS.n408 5.2005
R3759 VSS.n406 VSS.n366 5.2005
R3760 VSS.n366 VSS.n365 5.2005
R3761 VSS.n381 VSS.n380 5.2005
R3762 VSS.n380 VSS.n379 5.2005
R3763 VSS.n197 VSS.t131 5.2005
R3764 VSS.n199 VSS.n197 5.2005
R3765 VSS.n676 VSS.n675 5.2005
R3766 VSS.n675 VSS.n674 5.2005
R3767 VSS.n202 VSS.n198 5.2005
R3768 VSS.n673 VSS.n198 5.2005
R3769 VSS.n671 VSS.n670 5.2005
R3770 VSS.n672 VSS.n671 5.2005
R3771 VSS.n951 VSS.n70 5.2005
R3772 VSS.n70 VSS.n69 5.2005
R3773 VSS.n953 VSS.n952 5.2005
R3774 VSS.n954 VSS.n953 5.2005
R3775 VSS.n71 VSS.n68 5.2005
R3776 VSS.n955 VSS.n68 5.2005
R3777 VSS.n958 VSS.n957 5.2005
R3778 VSS.n957 VSS.n956 5.2005
R3779 VSS.n67 VSS.n40 5.2005
R3780 VSS.n40 VSS.n39 5.2005
R3781 VSS.n964 VSS.t61 5.2005
R3782 VSS.n965 VSS.n964 5.2005
R3783 VSS.n361 VSS.n37 5.2005
R3784 VSS.n966 VSS.n37 5.2005
R3785 VSS.n969 VSS.n968 5.2005
R3786 VSS.n968 VSS.n967 5.2005
R3787 VSS.n60 VSS.n36 5.2005
R3788 VSS.n38 VSS.n36 5.2005
R3789 VSS.n59 VSS.n58 5.2005
R3790 VSS.n58 VSS.n57 5.2005
R3791 VSS.n55 VSS.n54 5.2005
R3792 VSS.n56 VSS.n55 5.2005
R3793 VSS.n973 VSS.n32 5.2005
R3794 VSS.n32 VSS.n31 5.2005
R3795 VSS.n975 VSS.n974 5.2005
R3796 VSS.n976 VSS.n975 5.2005
R3797 VSS.t248 VSS.n30 5.2005
R3798 VSS.n977 VSS.n30 5.2005
R3799 VSS.n980 VSS.n979 5.2005
R3800 VSS.n979 VSS.n978 5.2005
R3801 VSS.n981 VSS.n26 5.2005
R3802 VSS.n26 VSS.n25 5.2005
R3803 VSS.n983 VSS.n982 5.2005
R3804 VSS.n984 VSS.n983 5.2005
R3805 VSS.n10 VSS.n8 5.2005
R3806 VSS.n985 VSS.n10 5.2005
R3807 VSS.n988 VSS.n987 5.2005
R3808 VSS.n987 VSS.n986 5.2005
R3809 VSS.n989 VSS.n988 5.2005
R3810 VSS.n990 VSS.n989 5.2005
R3811 VSS.n8 VSS.n6 5.2005
R3812 VSS.n6 VSS.n4 5.2005
R3813 VSS.n982 VSS.n27 5.2005
R3814 VSS.n45 VSS.n27 5.2005
R3815 VSS.n981 VSS.n28 5.2005
R3816 VSS.n46 VSS.n28 5.2005
R3817 VSS.n980 VSS.n29 5.2005
R3818 VSS.n47 VSS.n29 5.2005
R3819 VSS.n48 VSS.t248 5.2005
R3820 VSS.n49 VSS.n48 5.2005
R3821 VSS.n974 VSS.n33 5.2005
R3822 VSS.n50 VSS.n33 5.2005
R3823 VSS.n973 VSS.n34 5.2005
R3824 VSS.n51 VSS.n34 5.2005
R3825 VSS.n54 VSS.n53 5.2005
R3826 VSS.n53 VSS.n52 5.2005
R3827 VSS.n59 VSS.n44 5.2005
R3828 VSS.n44 VSS.n43 5.2005
R3829 VSS.n61 VSS.n60 5.2005
R3830 VSS.n62 VSS.n61 5.2005
R3831 VSS.n969 VSS.n35 5.2005
R3832 VSS.n63 VSS.n35 5.2005
R3833 VSS.n361 VSS.n41 5.2005
R3834 VSS.n64 VSS.n41 5.2005
R3835 VSS.t61 VSS.n963 5.2005
R3836 VSS.n963 VSS.n962 5.2005
R3837 VSS.n67 VSS.n42 5.2005
R3838 VSS.n961 VSS.n42 5.2005
R3839 VSS.n959 VSS.n958 5.2005
R3840 VSS.n960 VSS.n959 5.2005
R3841 VSS.n71 VSS.n66 5.2005
R3842 VSS.n66 VSS.n65 5.2005
R3843 VSS.n952 VSS.n72 5.2005
R3844 VSS.n935 VSS.n72 5.2005
R3845 VSS.n951 VSS.n73 5.2005
R3846 VSS.n936 VSS.n73 5.2005
R3847 VSS.n950 VSS.n949 5.2005
R3848 VSS.n949 VSS.n948 5.2005
R3849 VSS.n947 VSS.n934 5.2005
R3850 VSS.n946 VSS.n945 5.2005
R3851 VSS.n944 VSS.n943 5.2005
R3852 VSS.n942 VSS.n941 5.2005
R3853 VSS.n940 VSS.n939 5.2005
R3854 VSS.n938 VSS.n937 5.2005
R3855 VSS.n5 VSS.n3 5.2005
R3856 VSS.n15 VSS.n13 5.2005
R3857 VSS.n17 VSS.n16 5.2005
R3858 VSS.n19 VSS.n18 5.2005
R3859 VSS.n20 VSS.n7 5.2005
R3860 VSS.n20 VSS.n11 5.2005
R3861 VSS.n23 VSS.n22 5.2005
R3862 VSS.n24 VSS.n9 5.2005
R3863 VSS.n684 VSS.n683 5.2005
R3864 VSS.n684 VSS.n188 5.2005
R3865 VSS.n686 VSS.n685 5.2005
R3866 VSS.n687 VSS.n686 5.2005
R3867 VSS.n765 VSS.n130 5.2005
R3868 VSS.n688 VSS.n130 5.2005
R3869 VSS.n690 VSS.n689 5.2005
R3870 VSS.n691 VSS.n690 5.2005
R3871 VSS.n759 VSS.n136 5.2005
R3872 VSS.n692 VSS.n136 5.2005
R3873 VSS.t401 VSS.n694 5.2005
R3874 VSS.n694 VSS.n693 5.2005
R3875 VSS.n697 VSS.n187 5.2005
R3876 VSS.n187 VSS.n186 5.2005
R3877 VSS.n698 VSS.t228 5.2005
R3878 VSS.n699 VSS.n698 5.2005
R3879 VSS.n755 VSS.n138 5.2005
R3880 VSS.n700 VSS.n138 5.2005
R3881 VSS.n702 VSS.n701 5.2005
R3882 VSS.n703 VSS.n702 5.2005
R3883 VSS.n749 VSS.n144 5.2005
R3884 VSS.n704 VSS.n144 5.2005
R3885 VSS.n747 VSS.n178 5.2005
R3886 VSS.n705 VSS.n178 5.2005
R3887 VSS.n746 VSS.n179 5.2005
R3888 VSS.n706 VSS.n179 5.2005
R3889 VSS.n707 VSS.n183 5.2005
R3890 VSS.n708 VSS.n707 5.2005
R3891 VSS.n740 VSS.n184 5.2005
R3892 VSS.n709 VSS.n184 5.2005
R3893 VSS.n739 VSS.n738 5.2005
R3894 VSS.n738 VSS.n737 5.2005
R3895 VSS.n715 VSS.n74 5.2005
R3896 VSS.n715 VSS.n714 5.2005
R3897 VSS.n718 VSS.n717 5.2005
R3898 VSS.n719 VSS.n713 5.2005
R3899 VSS.n721 VSS.n720 5.2005
R3900 VSS.n723 VSS.n712 5.2005
R3901 VSS.n726 VSS.n725 5.2005
R3902 VSS.n727 VSS.n711 5.2005
R3903 VSS.n729 VSS.n728 5.2005
R3904 VSS.n731 VSS.n710 5.2005
R3905 VSS.n734 VSS.n733 5.2005
R3906 VSS.n735 VSS.n185 5.2005
R3907 VSS.n683 VSS.n682 5.2005
R3908 VSS.n682 VSS.n681 5.2005
R3909 VSS.n685 VSS.n131 5.2005
R3910 VSS.n133 VSS.n131 5.2005
R3911 VSS.n765 VSS.n764 5.2005
R3912 VSS.n764 VSS.n763 5.2005
R3913 VSS.n689 VSS.n132 5.2005
R3914 VSS.n762 VSS.n132 5.2005
R3915 VSS.n760 VSS.n759 5.2005
R3916 VSS.n761 VSS.n760 5.2005
R3917 VSS.t401 VSS.n135 5.2005
R3918 VSS.n135 VSS.n134 5.2005
R3919 VSS.n697 VSS.n696 5.2005
R3920 VSS.n696 VSS.n695 5.2005
R3921 VSS.t228 VSS.n139 5.2005
R3922 VSS.n141 VSS.n139 5.2005
R3923 VSS.n755 VSS.n754 5.2005
R3924 VSS.n754 VSS.n753 5.2005
R3925 VSS.n701 VSS.n140 5.2005
R3926 VSS.n752 VSS.n140 5.2005
R3927 VSS.n750 VSS.n749 5.2005
R3928 VSS.n751 VSS.n750 5.2005
R3929 VSS.n747 VSS.n143 5.2005
R3930 VSS.n143 VSS.n142 5.2005
R3931 VSS.n746 VSS.n745 5.2005
R3932 VSS.n745 VSS.n744 5.2005
R3933 VSS.n183 VSS.n180 5.2005
R3934 VSS.n743 VSS.n180 5.2005
R3935 VSS.n741 VSS.n740 5.2005
R3936 VSS.n742 VSS.n741 5.2005
R3937 VSS.n739 VSS.n182 5.2005
R3938 VSS.n182 VSS.n181 5.2005
R3939 VSS.n201 VSS.n200 5.2005
R3940 VSS.n619 VSS.n618 5.2005
R3941 VSS.n621 VSS.n620 5.2005
R3942 VSS.n623 VSS.n616 5.2005
R3943 VSS.n626 VSS.n625 5.2005
R3944 VSS.n631 VSS.n615 5.2005
R3945 VSS.n633 VSS.n632 5.2005
R3946 VSS.n635 VSS.n614 5.2005
R3947 VSS.n638 VSS.n637 5.2005
R3948 VSS.n644 VSS.n446 5.2005
R3949 VSS.n650 VSS.n207 5.2005
R3950 VSS.n650 VSS.n444 5.2005
R3951 VSS.n649 VSS.n445 5.2005
R3952 VSS.n647 VSS.n646 5.2005
R3953 VSS.n113 VSS.n112 4.7005
R3954 VSS.n384 VSS.n370 4.6486
R3955 VSS.n390 VSS.n372 4.6486
R3956 VSS.n396 VSS.n369 4.6486
R3957 VSS.n397 VSS.n374 4.6486
R3958 VSS.n246 VSS.n244 4.6486
R3959 VSS.n348 VSS.n243 4.6486
R3960 VSS.n344 VSS.n242 4.6486
R3961 VSS.n340 VSS.n241 4.6486
R3962 VSS.n336 VSS.n240 4.6486
R3963 VSS.n911 VSS.n78 4.6486
R3964 VSS.n915 VSS.n77 4.6486
R3965 VSS.n919 VSS.n76 4.6486
R3966 VSS.n922 VSS.n75 4.6486
R3967 VSS.n934 VSS.n933 4.6486
R3968 VSS.n944 VSS.n932 4.6486
R3969 VSS.n940 VSS.n931 4.6486
R3970 VSS.n14 VSS.n5 4.6486
R3971 VSS.n16 VSS.n12 4.6486
R3972 VSS.n717 VSS.n716 4.6486
R3973 VSS.n722 VSS.n721 4.6486
R3974 VSS.n725 VSS.n724 4.6486
R3975 VSS.n730 VSS.n729 4.6486
R3976 VSS.n733 VSS.n732 4.6486
R3977 VSS.n387 VSS.n370 4.6486
R3978 VSS.n388 VSS.n372 4.6486
R3979 VSS.n393 VSS.n369 4.6486
R3980 VSS.n399 VSS.n374 4.6486
R3981 VSS.n732 VSS.n185 4.6486
R3982 VSS.n731 VSS.n730 4.6486
R3983 VSS.n724 VSS.n711 4.6486
R3984 VSS.n723 VSS.n722 4.6486
R3985 VSS.n716 VSS.n713 4.6486
R3986 VSS.n15 VSS.n14 4.6486
R3987 VSS.n19 VSS.n12 4.6486
R3988 VSS.n937 VSS.n931 4.6486
R3989 VSS.n941 VSS.n932 4.6486
R3990 VSS.n945 VSS.n933 4.6486
R3991 VSS.n908 VSS.n78 4.6486
R3992 VSS.n912 VSS.n77 4.6486
R3993 VSS.n916 VSS.n76 4.6486
R3994 VSS.n920 VSS.n75 4.6486
R3995 VSS.n333 VSS.n240 4.6486
R3996 VSS.n337 VSS.n241 4.6486
R3997 VSS.n341 VSS.n242 4.6486
R3998 VSS.n345 VSS.n243 4.6486
R3999 VSS.n349 VSS.n244 4.6486
R4000 VSS.n495 VSS.n493 4.59524
R4001 VSS.n610 VSS.n609 4.5005
R4002 VSS.n608 VSS.n607 4.5005
R4003 VSS.n606 VSS.n531 4.5005
R4004 VSS.n596 VSS.n595 4.5005
R4005 VSS.n594 VSS.n593 4.5005
R4006 VSS.n579 VSS.n533 4.5005
R4007 VSS.n578 VSS.n577 4.5005
R4008 VSS.n576 VSS.n575 4.5005
R4009 VSS.n574 VSS.n553 4.5005
R4010 VSS.n573 VSS.n572 4.5005
R4011 VSS.n571 VSS.n570 4.5005
R4012 VSS.n904 VSS.n903 4.5005
R4013 VSS.n898 VSS.n821 4.5005
R4014 VSS.n897 VSS.n896 4.5005
R4015 VSS.n895 VSS.n894 4.5005
R4016 VSS.n832 VSS.n823 4.5005
R4017 VSS.n874 VSS.n873 4.5005
R4018 VSS.n872 VSS.n842 4.5005
R4019 VSS.n871 VSS.n870 4.5005
R4020 VSS.n869 VSS.n843 4.5005
R4021 VSS.n868 VSS.n867 4.5005
R4022 VSS.n866 VSS.n865 4.5005
R4023 VSS.n469 VSS.n468 4.5005
R4024 VSS.n483 VSS.n482 4.5005
R4025 VSS.n454 VSS.n453 4.5005
R4026 VSS.n512 VSS.n511 4.5005
R4027 VSS.n501 VSS.n500 4.5005
R4028 VSS.n522 VSS.n521 4.5005
R4029 VSS.n794 VSS.n99 4.48215
R4030 VSS.n805 VSS.n804 4.48215
R4031 VSS.n808 VSS.n807 4.48215
R4032 VSS.n98 VSS.n92 4.48215
R4033 VSS.n228 VSS.n91 4.48215
R4034 VSS.n757 VSS.n137 4.47524
R4035 VSS.n905 VSS.n820 4.47524
R4036 VSS.n115 VSS.n106 4.34122
R4037 VSS.n783 VSS.n782 4.34122
R4038 VSS.n176 VSS.n150 4.34122
R4039 VSS.n151 VSS.n149 4.34122
R4040 VSS.n170 VSS.n148 4.34122
R4041 VSS.n166 VSS.n147 4.34122
R4042 VSS.n162 VSS.n146 4.34122
R4043 VSS.n210 VSS.n208 4.34122
R4044 VSS.n222 VSS.n209 4.34122
R4045 VSS.n218 VSS.n217 4.34122
R4046 VSS.n782 VSS.n781 4.34122
R4047 VSS.n784 VSS.n115 4.34122
R4048 VSS.n159 VSS.n146 4.34122
R4049 VSS.n163 VSS.n147 4.34122
R4050 VSS.n167 VSS.n148 4.34122
R4051 VSS.n171 VSS.n149 4.34122
R4052 VSS.n176 VSS.n175 4.34122
R4053 VSS.n217 VSS.n216 4.34122
R4054 VSS.n219 VSS.n209 4.34122
R4055 VSS.n223 VSS.n208 4.34122
R4056 VSS.n237 VSS.n235 4.34122
R4057 VSS.n662 VSS.n234 4.34122
R4058 VSS.n658 VSS.n233 4.34122
R4059 VSS.n654 VSS.n232 4.34122
R4060 VSS.n236 VSS.n87 4.34122
R4061 VSS.n435 VSS.n88 4.34122
R4062 VSS.n431 VSS.n89 4.34122
R4063 VSS.n427 VSS.n90 4.34122
R4064 VSS.n423 VSS.n422 4.34122
R4065 VSS.n617 VSS.n201 4.34122
R4066 VSS.n622 VSS.n621 4.34122
R4067 VSS.n625 VSS.n624 4.34122
R4068 VSS.n634 VSS.n633 4.34122
R4069 VSS.n637 VSS.n636 4.34122
R4070 VSS.n649 VSS.n648 4.34122
R4071 VSS.n648 VSS.n647 4.34122
R4072 VSS.n651 VSS.n232 4.34122
R4073 VSS.n655 VSS.n233 4.34122
R4074 VSS.n659 VSS.n234 4.34122
R4075 VSS.n663 VSS.n235 4.34122
R4076 VSS.n636 VSS.n446 4.34122
R4077 VSS.n635 VSS.n634 4.34122
R4078 VSS.n624 VSS.n615 4.34122
R4079 VSS.n623 VSS.n622 4.34122
R4080 VSS.n618 VSS.n617 4.34122
R4081 VSS.n436 VSS.n87 4.34122
R4082 VSS.n432 VSS.n88 4.34122
R4083 VSS.n428 VSS.n89 4.34122
R4084 VSS.n424 VSS.n90 4.34122
R4085 VSS.n422 VSS.n421 4.34122
R4086 VSS.n22 VSS.n21 4.20229
R4087 VSS.n21 VSS.n9 4.20229
R4088 VSS.n749 VSS.n748 4.10404
R4089 VSS.n205 VSS.n204 4.08867
R4090 VSS.n113 VSS.n0 3.803
R4091 VSS.n404 VSS.n375 3.72542
R4092 VSS.n927 VSS.n81 3.72542
R4093 VSS.n404 VSS.n403 3.72542
R4094 VSS.n927 VSS.n926 3.72542
R4095 VSS.n792 VSS.n791 3.6553
R4096 VSS.n797 VSS.n796 3.6553
R4097 VSS.t428 VSS.n205 3.3918
R4098 VSS.t461 VSS.t122 3.28333
R4099 VSS.t463 VSS.t121 3.28333
R4100 VSS.t457 VSS.t423 3.28333
R4101 VSS.t465 VSS.t422 3.28333
R4102 VSS.t467 VSS.t421 3.28333
R4103 VSS.t455 VSS.t173 3.28333
R4104 VSS.t469 VSS.t172 3.28333
R4105 VSS.t473 VSS.t171 3.28333
R4106 VSS.t475 VSS.t195 3.28333
R4107 VSS.t477 VSS.t194 3.28333
R4108 VSS.t479 VSS.t193 3.28333
R4109 VSS.t471 VSS.t91 3.28333
R4110 VSS.t316 VSS.n129 3.28333
R4111 VSS.n772 VSS.t419 3.28333
R4112 VSS.n818 VSS.t410 2.82659
R4113 VSS.n613 VSS.n0 2.62175
R4114 VSS.n611 VSS.n137 2.25898
R4115 VSS.n905 VSS.n1 2.25898
R4116 VSS.n571 VSS.n559 1.73942
R4117 VSS.n866 VSS.n854 1.73942
R4118 VSS.n613 VSS.n612 1.72175
R4119 VSS.n737 VSS.n709 1.1255
R4120 VSS.n709 VSS.n708 1.1255
R4121 VSS.n708 VSS.n706 1.1255
R4122 VSS.n706 VSS.n705 1.1255
R4123 VSS.n705 VSS.n704 1.1255
R4124 VSS.n704 VSS.n703 1.1255
R4125 VSS.n703 VSS.n700 1.1255
R4126 VSS.n700 VSS.n699 1.1255
R4127 VSS.n699 VSS.n186 1.1255
R4128 VSS.n693 VSS.n186 1.1255
R4129 VSS.n693 VSS.n692 1.1255
R4130 VSS.n692 VSS.n691 1.1255
R4131 VSS.n691 VSS.n688 1.1255
R4132 VSS.n688 VSS.n687 1.1255
R4133 VSS.n687 VSS.n188 1.1255
R4134 VSS.n376 VSS.n188 1.1255
R4135 VSS.n377 VSS.n376 1.1255
R4136 VSS.n378 VSS.n377 1.1255
R4137 VSS.n386 VSS.n385 1.1255
R4138 VSS.n389 VSS.n386 1.1255
R4139 VSS.n391 VSS.n389 1.1255
R4140 VSS.n392 VSS.n391 1.1255
R4141 VSS.n394 VSS.n392 1.1255
R4142 VSS.n395 VSS.n394 1.1255
R4143 VSS.n398 VSS.n395 1.1255
R4144 VSS.n400 VSS.n398 1.1255
R4145 VSS.n401 VSS.n400 1.1255
R4146 VSS.n742 VSS.n181 1.1255
R4147 VSS.n743 VSS.n742 1.1255
R4148 VSS.n744 VSS.n743 1.1255
R4149 VSS.n744 VSS.n142 1.1255
R4150 VSS.n751 VSS.n142 1.1255
R4151 VSS.n752 VSS.n751 1.1255
R4152 VSS.n753 VSS.n752 1.1255
R4153 VSS.n753 VSS.n141 1.1255
R4154 VSS.n695 VSS.n141 1.1255
R4155 VSS.n695 VSS.n134 1.1255
R4156 VSS.n761 VSS.n134 1.1255
R4157 VSS.n762 VSS.n761 1.1255
R4158 VSS.n763 VSS.n762 1.1255
R4159 VSS.n763 VSS.n133 1.1255
R4160 VSS.n681 VSS.n133 1.1255
R4161 VSS.n681 VSS.n680 1.1255
R4162 VSS.n680 VSS.n679 1.1255
R4163 VSS.n679 VSS.n192 1.1255
R4164 VSS.n735 VSS.n734 1.1255
R4165 VSS.n734 VSS.n710 1.1255
R4166 VSS.n728 VSS.n710 1.1255
R4167 VSS.n728 VSS.n727 1.1255
R4168 VSS.n727 VSS.n726 1.1255
R4169 VSS.n726 VSS.n712 1.1255
R4170 VSS.n720 VSS.n712 1.1255
R4171 VSS.n720 VSS.n719 1.1255
R4172 VSS.n719 VSS.n718 1.1255
R4173 VSS.n250 VSS.n248 1.1255
R4174 VSS.n321 VSS.n250 1.1255
R4175 VSS.n322 VSS.n321 1.1255
R4176 VSS.n322 VSS.n320 1.1255
R4177 VSS.n320 VSS.n319 1.1255
R4178 VSS.n319 VSS.n256 1.1255
R4179 VSS.n308 VSS.n256 1.1255
R4180 VSS.n308 VSS.n307 1.1255
R4181 VSS.n307 VSS.n306 1.1255
R4182 VSS.n306 VSS.n263 1.1255
R4183 VSS.n294 VSS.n263 1.1255
R4184 VSS.n295 VSS.n294 1.1255
R4185 VSS.n295 VSS.n293 1.1255
R4186 VSS.n293 VSS.n292 1.1255
R4187 VSS.n292 VSS.n270 1.1255
R4188 VSS.n280 VSS.n270 1.1255
R4189 VSS.n280 VSS.n279 1.1255
R4190 VSS.n279 VSS.n84 1.1255
R4191 VSS.n335 VSS.n334 1.1255
R4192 VSS.n338 VSS.n335 1.1255
R4193 VSS.n339 VSS.n338 1.1255
R4194 VSS.n342 VSS.n339 1.1255
R4195 VSS.n343 VSS.n342 1.1255
R4196 VSS.n346 VSS.n343 1.1255
R4197 VSS.n347 VSS.n346 1.1255
R4198 VSS.n350 VSS.n347 1.1255
R4199 VSS.n351 VSS.n350 1.1255
R4200 VSS.n328 VSS.n247 1.1255
R4201 VSS.n328 VSS.n327 1.1255
R4202 VSS.n327 VSS.n326 1.1255
R4203 VSS.n326 VSS.n253 1.1255
R4204 VSS.n315 VSS.n253 1.1255
R4205 VSS.n315 VSS.n314 1.1255
R4206 VSS.n314 VSS.n313 1.1255
R4207 VSS.n313 VSS.n260 1.1255
R4208 VSS.n302 VSS.n260 1.1255
R4209 VSS.n302 VSS.n301 1.1255
R4210 VSS.n301 VSS.n300 1.1255
R4211 VSS.n300 VSS.n266 1.1255
R4212 VSS.n287 VSS.n266 1.1255
R4213 VSS.n288 VSS.n287 1.1255
R4214 VSS.n288 VSS.n286 1.1255
R4215 VSS.n286 VSS.n285 1.1255
R4216 VSS.n285 VSS.n274 1.1255
R4217 VSS.n274 VSS.n83 1.1255
R4218 VSS.n909 VSS.n907 1.1255
R4219 VSS.n910 VSS.n909 1.1255
R4220 VSS.n913 VSS.n910 1.1255
R4221 VSS.n914 VSS.n913 1.1255
R4222 VSS.n917 VSS.n914 1.1255
R4223 VSS.n918 VSS.n917 1.1255
R4224 VSS.n921 VSS.n918 1.1255
R4225 VSS.n923 VSS.n921 1.1255
R4226 VSS.n924 VSS.n923 1.1255
R4227 VSS.n936 VSS.n935 1.1255
R4228 VSS.n935 VSS.n65 1.1255
R4229 VSS.n960 VSS.n65 1.1255
R4230 VSS.n961 VSS.n960 1.1255
R4231 VSS.n962 VSS.n961 1.1255
R4232 VSS.n962 VSS.n64 1.1255
R4233 VSS.n64 VSS.n63 1.1255
R4234 VSS.n63 VSS.n62 1.1255
R4235 VSS.n62 VSS.n43 1.1255
R4236 VSS.n52 VSS.n43 1.1255
R4237 VSS.n52 VSS.n51 1.1255
R4238 VSS.n51 VSS.n50 1.1255
R4239 VSS.n50 VSS.n49 1.1255
R4240 VSS.n49 VSS.n47 1.1255
R4241 VSS.n47 VSS.n46 1.1255
R4242 VSS.n46 VSS.n45 1.1255
R4243 VSS.n45 VSS.n4 1.1255
R4244 VSS.n990 VSS.n4 1.1255
R4245 VSS.n939 VSS.n938 1.1255
R4246 VSS.n942 VSS.n939 1.1255
R4247 VSS.n943 VSS.n942 1.1255
R4248 VSS.n946 VSS.n943 1.1255
R4249 VSS.n947 VSS.n946 1.1255
R4250 VSS.n954 VSS.n69 1.1255
R4251 VSS.n955 VSS.n954 1.1255
R4252 VSS.n956 VSS.n955 1.1255
R4253 VSS.n956 VSS.n39 1.1255
R4254 VSS.n965 VSS.n39 1.1255
R4255 VSS.n966 VSS.n965 1.1255
R4256 VSS.n967 VSS.n966 1.1255
R4257 VSS.n967 VSS.n38 1.1255
R4258 VSS.n57 VSS.n38 1.1255
R4259 VSS.n57 VSS.n56 1.1255
R4260 VSS.n56 VSS.n31 1.1255
R4261 VSS.n976 VSS.n31 1.1255
R4262 VSS.n977 VSS.n976 1.1255
R4263 VSS.n978 VSS.n977 1.1255
R4264 VSS.n978 VSS.n25 1.1255
R4265 VSS.n984 VSS.n25 1.1255
R4266 VSS.n985 VSS.n984 1.1255
R4267 VSS.n986 VSS.n985 1.1255
R4268 VSS.n13 VSS.n3 1.1255
R4269 VSS.n17 VSS.n13 1.1255
R4270 VSS.n18 VSS.n17 1.1255
R4271 VSS.n18 VSS.n11 1.1255
R4272 VSS.n23 VSS.n11 1.1255
R4273 VSS.n769 VSS.n768 0.9905
R4274 VSS.n607 VSS.n606 0.9005
R4275 VSS.n579 VSS.n578 0.9005
R4276 VSS.n575 VSS.n574 0.9005
R4277 VSS.n574 VSS.n573 0.9005
R4278 VSS.n869 VSS.n868 0.9005
R4279 VSS.n870 VSS.n869 0.9005
R4280 VSS.n874 VSS.n842 0.9005
R4281 VSS.n898 VSS.n897 0.9005
R4282 VSS.n112 VSS.n111 0.9005
R4283 VSS.n111 VSS.n110 0.9005
R4284 VSS.n110 VSS.n109 0.9005
R4285 VSS.n109 VSS.n108 0.9005
R4286 VSS.n108 VSS.n107 0.9005
R4287 VSS.n226 VSS.n225 0.878
R4288 VSS.n385 VSS.n378 0.878
R4289 VSS.n334 VSS.n248 0.878
R4290 VSS.n938 VSS.n936 0.878
R4291 VSS.n610 VSS.n530 0.8405
R4292 VSS.n903 VSS.n902 0.8405
R4293 VSS.n627 VSS.t485 0.8195
R4294 VSS.n627 VSS.t486 0.8195
R4295 VSS.n628 VSS.t482 0.8195
R4296 VSS.n628 VSS.t483 0.8195
R4297 VSS.n580 VSS.n579 0.8105
R4298 VSS.n875 VSS.n874 0.8105
R4299 VSS.n560 VSS.n559 0.799908
R4300 VSS.n855 VSS.n854 0.799908
R4301 VSS.n592 VSS.n532 0.7805
R4302 VSS.n893 VSS.n892 0.7805
R4303 VSS.n160 VSS.n153 0.7655
R4304 VSS.n420 VSS.n419 0.7655
R4305 VSS.n672 VSS.n200 0.7655
R4306 VSS.n405 VSS.n404 0.73879
R4307 VSS.n928 VSS.n927 0.73879
R4308 VSS.n578 VSS.n552 0.6905
R4309 VSS.n848 VSS.n842 0.6905
R4310 VSS.n156 VSS.n153 0.6755
R4311 VSS.n156 VSS.n155 0.6755
R4312 VSS.n155 VSS.n117 0.6755
R4313 VSS.n778 VSS.n117 0.6755
R4314 VSS.n779 VSS.n778 0.6755
R4315 VSS.n780 VSS.n779 0.6755
R4316 VSS.n780 VSS.n114 0.6755
R4317 VSS.n785 VSS.n114 0.6755
R4318 VSS.n786 VSS.n785 0.6755
R4319 VSS.n161 VSS.n160 0.6755
R4320 VSS.n164 VSS.n161 0.6755
R4321 VSS.n165 VSS.n164 0.6755
R4322 VSS.n168 VSS.n165 0.6755
R4323 VSS.n169 VSS.n168 0.6755
R4324 VSS.n172 VSS.n169 0.6755
R4325 VSS.n173 VSS.n172 0.6755
R4326 VSS.n174 VSS.n173 0.6755
R4327 VSS.n174 VSS.n152 0.6755
R4328 VSS.n152 VSS.n127 0.6755
R4329 VSS.n768 VSS.n127 0.6755
R4330 VSS.n770 VSS.n769 0.6755
R4331 VSS.n770 VSS.n126 0.6755
R4332 VSS.n214 VSS.n126 0.6755
R4333 VSS.n215 VSS.n214 0.6755
R4334 VSS.n215 VSS.n211 0.6755
R4335 VSS.n220 VSS.n211 0.6755
R4336 VSS.n221 VSS.n220 0.6755
R4337 VSS.n224 VSS.n221 0.6755
R4338 VSS.n225 VSS.n224 0.6755
R4339 VSS.n788 VSS.n103 0.6755
R4340 VSS.n799 VSS.n103 0.6755
R4341 VSS.n800 VSS.n799 0.6755
R4342 VSS.n801 VSS.n800 0.6755
R4343 VSS.n801 VSS.n102 0.6755
R4344 VSS.n102 VSS.n96 0.6755
R4345 VSS.n811 VSS.n96 0.6755
R4346 VSS.n812 VSS.n811 0.6755
R4347 VSS.n813 VSS.n812 0.6755
R4348 VSS.n813 VSS.n95 0.6755
R4349 VSS.n226 VSS.n95 0.6755
R4350 VSS.n646 VSS.n445 0.6755
R4351 VSS.n445 VSS.n444 0.6755
R4352 VSS.n652 VSS.n444 0.6755
R4353 VSS.n653 VSS.n652 0.6755
R4354 VSS.n656 VSS.n653 0.6755
R4355 VSS.n657 VSS.n656 0.6755
R4356 VSS.n660 VSS.n657 0.6755
R4357 VSS.n661 VSS.n660 0.6755
R4358 VSS.n664 VSS.n661 0.6755
R4359 VSS.n665 VSS.n664 0.6755
R4360 VSS.n437 VSS.n434 0.6755
R4361 VSS.n434 VSS.n433 0.6755
R4362 VSS.n433 VSS.n430 0.6755
R4363 VSS.n430 VSS.n429 0.6755
R4364 VSS.n429 VSS.n426 0.6755
R4365 VSS.n426 VSS.n425 0.6755
R4366 VSS.n425 VSS.n238 0.6755
R4367 VSS.n420 VSS.n238 0.6755
R4368 VSS.n673 VSS.n672 0.6755
R4369 VSS.n674 VSS.n673 0.6755
R4370 VSS.n674 VSS.n199 0.6755
R4371 VSS.n379 VSS.n199 0.6755
R4372 VSS.n379 VSS.n365 0.6755
R4373 VSS.n409 VSS.n365 0.6755
R4374 VSS.n410 VSS.n409 0.6755
R4375 VSS.n411 VSS.n410 0.6755
R4376 VSS.n411 VSS.n357 0.6755
R4377 VSS.n418 VSS.n357 0.6755
R4378 VSS.n638 VSS.n614 0.6755
R4379 VSS.n632 VSS.n614 0.6755
R4380 VSS.n632 VSS.n631 0.6755
R4381 VSS.n626 VSS.n616 0.6755
R4382 VSS.n620 VSS.n616 0.6755
R4383 VSS.n620 VSS.n619 0.6755
R4384 VSS.n619 VSS.n200 0.6755
R4385 VSS.n666 VSS.n443 0.653
R4386 VSS.n402 VSS.n192 0.653
R4387 VSS.n714 VSS.n181 0.653
R4388 VSS.n352 VSS.n247 0.653
R4389 VSS.n925 VSS.n83 0.653
R4390 VSS.n948 VSS.n69 0.653
R4391 VSS.n986 VSS.n24 0.653
R4392 VSS.n612 VSS.n611 0.59737
R4393 VSS.n993 VSS.n1 0.59737
R4394 VSS.n570 VSS.n555 0.5855
R4395 VSS.n865 VSS.n850 0.5855
R4396 VSS.n948 VSS.n947 0.563
R4397 VSS.n24 VSS.n23 0.563
R4398 VSS.n488 VSS.n486 0.5405
R4399 VSS.n737 VSS.n736 0.518
R4400 VSS.n906 VSS.n84 0.518
R4401 VSS.n991 VSS.n990 0.518
R4402 VSS.n597 VSS.n596 0.5105
R4403 VSS.n894 VSS.n831 0.5105
R4404 VSS.n21 VSS.n7 0.500354
R4405 VSS.n787 VSS.n786 0.47417
R4406 VSS.n666 VSS.n665 0.4505
R4407 VSS.n442 VSS.n437 0.4505
R4408 VSS.n419 VSS.n418 0.4505
R4409 VSS.n643 VSS.n638 0.4505
R4410 VSS.n115 VSS.n105 0.430889
R4411 VSS.n782 VSS.n105 0.430889
R4412 VSS.n177 VSS.n176 0.430889
R4413 VSS.n177 VSS.n149 0.430889
R4414 VSS.n177 VSS.n148 0.430889
R4415 VSS.n177 VSS.n147 0.430889
R4416 VSS.n177 VSS.n146 0.430889
R4417 VSS.n231 VSS.n208 0.430889
R4418 VSS.n231 VSS.n209 0.430889
R4419 VSS.n217 VSS.n212 0.430889
R4420 VSS.n668 VSS.n235 0.430889
R4421 VSS.n668 VSS.n234 0.430889
R4422 VSS.n668 VSS.n233 0.430889
R4423 VSS.n668 VSS.n232 0.430889
R4424 VSS.n817 VSS.n87 0.430889
R4425 VSS.n817 VSS.n88 0.430889
R4426 VSS.n817 VSS.n89 0.430889
R4427 VSS.n817 VSS.n90 0.430889
R4428 VSS.n422 VSS.n355 0.430889
R4429 VSS.n617 VSS.n190 0.430889
R4430 VSS.n622 VSS.n190 0.430889
R4431 VSS.n624 VSS.n190 0.430889
R4432 VSS.n634 VSS.n190 0.430889
R4433 VSS.n636 VSS.n190 0.430889
R4434 VSS.n648 VSS.n207 0.430889
R4435 VSS.n450 VSS.t434 0.41
R4436 VSS.n450 VSS.t40 0.41
R4437 VSS.n485 VSS.t189 0.41
R4438 VSS.n485 VSS.t187 0.41
R4439 VSS.n487 VSS.t326 0.41
R4440 VSS.n487 VSS.t416 0.41
R4441 VSS.n518 VSS.t160 0.41
R4442 VSS.n518 VSS.t315 0.41
R4443 VSS.n611 VSS.n610 0.409133
R4444 VSS.n903 VSS.n1 0.409133
R4445 VSS.n609 VSS.n608 0.4005
R4446 VSS.n608 VSS.n531 0.4005
R4447 VSS.n595 VSS.n531 0.4005
R4448 VSS.n595 VSS.n594 0.4005
R4449 VSS.n594 VSS.n533 0.4005
R4450 VSS.n577 VSS.n533 0.4005
R4451 VSS.n577 VSS.n576 0.4005
R4452 VSS.n576 VSS.n553 0.4005
R4453 VSS.n572 VSS.n553 0.4005
R4454 VSS.n572 VSS.n571 0.4005
R4455 VSS.n867 VSS.n866 0.4005
R4456 VSS.n867 VSS.n843 0.4005
R4457 VSS.n871 VSS.n843 0.4005
R4458 VSS.n872 VSS.n871 0.4005
R4459 VSS.n873 VSS.n872 0.4005
R4460 VSS.n873 VSS.n823 0.4005
R4461 VSS.n895 VSS.n823 0.4005
R4462 VSS.n896 VSS.n895 0.4005
R4463 VSS.n896 VSS.n821 0.4005
R4464 VSS.n904 VSS.n821 0.4005
R4465 VSS.n486 VSS.n484 0.3875
R4466 VSS.n646 VSS.n645 0.37175
R4467 VSS.n489 VSS.n488 0.3695
R4468 VSS.n631 VSS.n630 0.3605
R4469 VSS.n736 VSS.n735 0.3605
R4470 VSS.n907 VSS.n906 0.3605
R4471 VSS.n991 VSS.n3 0.3605
R4472 VSS.n402 VSS.n401 0.338
R4473 VSS.n718 VSS.n714 0.338
R4474 VSS.n352 VSS.n351 0.338
R4475 VSS.n925 VSS.n924 0.338
R4476 VSS.n569 VSS.n568 0.3305
R4477 VSS.n864 VSS.n863 0.3305
R4478 VSS.n630 VSS.n626 0.3155
R4479 VSS.n573 VSS.n555 0.3155
R4480 VSS.n868 VSS.n850 0.3155
R4481 VSS.n645 VSS.n644 0.28175
R4482 VSS.n405 VSS.n370 0.2772
R4483 VSS.n405 VSS.n372 0.2772
R4484 VSS.n405 VSS.n369 0.2772
R4485 VSS.n405 VSS.n374 0.2772
R4486 VSS.n354 VSS.n244 0.2772
R4487 VSS.n354 VSS.n243 0.2772
R4488 VSS.n354 VSS.n242 0.2772
R4489 VSS.n354 VSS.n241 0.2772
R4490 VSS.n354 VSS.n240 0.2772
R4491 VSS.n928 VSS.n78 0.2772
R4492 VSS.n928 VSS.n77 0.2772
R4493 VSS.n928 VSS.n76 0.2772
R4494 VSS.n928 VSS.n75 0.2772
R4495 VSS.n950 VSS.n933 0.2772
R4496 VSS.n950 VSS.n932 0.2772
R4497 VSS.n950 VSS.n931 0.2772
R4498 VSS.n14 VSS.n7 0.2772
R4499 VSS.n12 VSS.n7 0.2772
R4500 VSS.n716 VSS.n74 0.2772
R4501 VSS.n722 VSS.n74 0.2772
R4502 VSS.n724 VSS.n74 0.2772
R4503 VSS.n730 VSS.n74 0.2772
R4504 VSS.n732 VSS.n74 0.2772
R4505 VSS.n526 VSS.n523 0.2705
R4506 VSS.n523 VSS.n517 0.2705
R4507 VSS.n517 VSS.n513 0.2705
R4508 VSS.n459 VSS.n455 0.2705
R4509 VSS.n455 VSS.n449 0.2705
R4510 VSS.n503 VSS.n502 0.2345
R4511 VSS.n460 VSS.n459 0.2345
R4512 VSS.n994 VSS.n0 0.2255
R4513 VSS.n443 VSS.n442 0.2255
R4514 VSS.n644 VSS.n643 0.2255
R4515 VSS.n471 VSS.n470 0.2165
R4516 VSS.n575 VSS.n552 0.2105
R4517 VSS.n870 VSS.n848 0.2105
R4518 VSS.n449 VSS.n2 0.206961
R4519 VSS.n556 VSS.t427 0.20525
R4520 VSS.n556 VSS.t425 0.20525
R4521 VSS.n557 VSS.t431 0.20525
R4522 VSS.n557 VSS.t429 0.20525
R4523 VSS.n561 VSS.t209 0.20525
R4524 VSS.n561 VSS.t420 0.20525
R4525 VSS.n562 VSS.t510 0.20525
R4526 VSS.n562 VSS.t353 0.20525
R4527 VSS.n564 VSS.t512 0.20525
R4528 VSS.n564 VSS.t202 0.20525
R4529 VSS.n566 VSS.t317 0.20525
R4530 VSS.n566 VSS.t500 0.20525
R4531 VSS.n554 VSS.t204 0.20525
R4532 VSS.n554 VSS.t124 0.20525
R4533 VSS.n534 VSS.t28 0.20525
R4534 VSS.n534 VSS.t26 0.20525
R4535 VSS.n598 VSS.t329 0.20525
R4536 VSS.n598 VSS.t199 0.20525
R4537 VSS.n599 VSS.t197 0.20525
R4538 VSS.n599 VSS.t175 0.20525
R4539 VSS.n601 VSS.t362 0.20525
R4540 VSS.n601 VSS.t126 0.20525
R4541 VSS.n603 VSS.t170 0.20525
R4542 VSS.n603 VSS.t213 0.20525
R4543 VSS.n527 VSS.t177 0.20525
R4544 VSS.n527 VSS.t130 0.20525
R4545 VSS.n528 VSS.t381 0.20525
R4546 VSS.n528 VSS.t179 0.20525
R4547 VSS.n899 VSS.t331 0.20525
R4548 VSS.n899 VSS.t319 0.20525
R4549 VSS.n900 VSS.t335 0.20525
R4550 VSS.n900 VSS.t333 0.20525
R4551 VSS.n824 VSS.t351 0.20525
R4552 VSS.n824 VSS.t375 0.20525
R4553 VSS.n829 VSS.t356 0.20525
R4554 VSS.n829 VSS.t358 0.20525
R4555 VSS.n827 VSS.t373 0.20525
R4556 VSS.n827 VSS.t364 0.20525
R4557 VSS.n826 VSS.t368 0.20525
R4558 VSS.n826 VSS.t370 0.20525
R4559 VSS.n840 VSS.t81 0.20525
R4560 VSS.n840 VSS.t79 0.20525
R4561 VSS.n849 VSS.t12 0.20525
R4562 VSS.n849 VSS.t10 0.20525
R4563 VSS.n861 VSS.t192 0.20525
R4564 VSS.n861 VSS.t168 0.20525
R4565 VSS.n859 VSS.t207 0.20525
R4566 VSS.n859 VSS.t418 0.20525
R4567 VSS.n857 VSS.t377 0.20525
R4568 VSS.n857 VSS.t166 0.20525
R4569 VSS.n856 VSS.t349 0.20525
R4570 VSS.n856 VSS.t379 0.20525
R4571 VSS.n851 VSS.t347 0.20525
R4572 VSS.n851 VSS.t345 0.20525
R4573 VSS.n852 VSS.t341 0.20525
R4574 VSS.n852 VSS.t339 0.20525
R4575 VSS.n447 VSS.t93 0.20525
R4576 VSS.n447 VSS.t1 0.20525
R4577 VSS.n462 VSS.t254 0.20525
R4578 VSS.n462 VSS.t256 0.20525
R4579 VSS.n461 VSS.t153 0.20525
R4580 VSS.n461 VSS.t151 0.20525
R4581 VSS.n467 VSS.t251 0.20525
R4582 VSS.n467 VSS.t252 0.20525
R4583 VSS.n465 VSS.t245 0.20525
R4584 VSS.n465 VSS.t250 0.20525
R4585 VSS.n464 VSS.t247 0.20525
R4586 VSS.n464 VSS.t249 0.20525
R4587 VSS.n476 VSS.t265 0.20525
R4588 VSS.n476 VSS.t267 0.20525
R4589 VSS.n474 VSS.t38 0.20525
R4590 VSS.n474 VSS.t36 0.20525
R4591 VSS.n472 VSS.t3 0.20525
R4592 VSS.n472 VSS.t159 0.20525
R4593 VSS.n481 VSS.t262 0.20525
R4594 VSS.n481 VSS.t263 0.20525
R4595 VSS.n479 VSS.t244 0.20525
R4596 VSS.n479 VSS.t261 0.20525
R4597 VSS.n478 VSS.t258 0.20525
R4598 VSS.n478 VSS.t260 0.20525
R4599 VSS.n456 VSS.t138 0.20525
R4600 VSS.n456 VSS.t140 0.20525
R4601 VSS.n457 VSS.t134 0.20525
R4602 VSS.n457 VSS.t136 0.20525
R4603 VSS.n451 VSS.t86 0.20525
R4604 VSS.n451 VSS.t90 0.20525
R4605 VSS.n452 VSS.t88 0.20525
R4606 VSS.n452 VSS.t85 0.20525
R4607 VSS.n505 VSS.t62 0.20525
R4608 VSS.n505 VSS.t64 0.20525
R4609 VSS.n504 VSS.t414 0.20525
R4610 VSS.n504 VSS.t320 0.20525
R4611 VSS.n510 VSS.t59 0.20525
R4612 VSS.n510 VSS.t60 0.20525
R4613 VSS.n508 VSS.t55 0.20525
R4614 VSS.n508 VSS.t57 0.20525
R4615 VSS.n507 VSS.t52 0.20525
R4616 VSS.n507 VSS.t54 0.20525
R4617 VSS.n490 VSS.t314 0.20525
R4618 VSS.n490 VSS.t155 0.20525
R4619 VSS.n494 VSS.t71 0.20525
R4620 VSS.n494 VSS.t73 0.20525
R4621 VSS.n491 VSS.t19 0.20525
R4622 VSS.n491 VSS.t505 0.20525
R4623 VSS.n496 VSS.t68 0.20525
R4624 VSS.n496 VSS.t69 0.20525
R4625 VSS.n498 VSS.t67 0.20525
R4626 VSS.n498 VSS.t48 0.20525
R4627 VSS.n497 VSS.t50 0.20525
R4628 VSS.n497 VSS.t66 0.20525
R4629 VSS.n514 VSS.t391 0.20525
R4630 VSS.n514 VSS.t393 0.20525
R4631 VSS.n515 VSS.t387 0.20525
R4632 VSS.n515 VSS.t389 0.20525
R4633 VSS.n524 VSS.t157 0.20525
R4634 VSS.n524 VSS.t5 0.20525
R4635 VSS.n519 VSS.t108 0.20525
R4636 VSS.n519 VSS.t114 0.20525
R4637 VSS.n520 VSS.t110 0.20525
R4638 VSS.n520 VSS.t112 0.20525
R4639 VSS.n606 VSS.n605 0.1955
R4640 VSS.n605 VSS.n597 0.1955
R4641 VSS.n568 VSS.n560 0.1955
R4642 VSS.n863 VSS.n855 0.1955
R4643 VSS.n831 VSS.n822 0.1955
R4644 VSS.n897 VSS.n822 0.1955
R4645 VSS.n567 VSS.n565 0.189974
R4646 VSS.n565 VSS.n563 0.189974
R4647 VSS.n588 VSS.n586 0.189974
R4648 VSS.n590 VSS.n588 0.189974
R4649 VSS.n583 VSS.n581 0.189974
R4650 VSS.n581 VSS.n546 0.189974
R4651 VSS.n546 VSS.n544 0.189974
R4652 VSS.n544 VSS.n542 0.189974
R4653 VSS.n542 VSS.n540 0.189974
R4654 VSS.n540 VSS.n538 0.189974
R4655 VSS.n604 VSS.n602 0.189974
R4656 VSS.n602 VSS.n600 0.189974
R4657 VSS.n830 VSS.n828 0.189974
R4658 VSS.n830 VSS.n825 0.189974
R4659 VSS.n880 VSS.n878 0.189974
R4660 VSS.n882 VSS.n880 0.189974
R4661 VSS.n884 VSS.n882 0.189974
R4662 VSS.n886 VSS.n884 0.189974
R4663 VSS.n888 VSS.n886 0.189974
R4664 VSS.n890 VSS.n888 0.189974
R4665 VSS.n839 VSS.n837 0.189974
R4666 VSS.n837 VSS.n835 0.189974
R4667 VSS.n860 VSS.n858 0.189974
R4668 VSS.n862 VSS.n860 0.189974
R4669 VSS.n468 VSS.n466 0.189974
R4670 VSS.n468 VSS.n463 0.189974
R4671 VSS.n482 VSS.n480 0.189974
R4672 VSS.n482 VSS.n477 0.189974
R4673 VSS.n511 VSS.n509 0.189974
R4674 VSS.n511 VSS.n506 0.189974
R4675 VSS.n500 VSS.n499 0.189974
R4676 VSS.n500 VSS.n495 0.189974
R4677 VSS.n788 VSS.n787 0.178383
R4678 VSS.n609 VSS.n137 0.167167
R4679 VSS.n905 VSS.n904 0.167167
R4680 VSS.n570 VSS.n569 0.1655
R4681 VSS.n865 VSS.n864 0.1655
R4682 VSS.n548 VSS.t104 0.1643
R4683 VSS.n548 VSS.t106 0.1643
R4684 VSS.n549 VSS.t98 0.1643
R4685 VSS.n549 VSS.t102 0.1643
R4686 VSS.n536 VSS.t480 0.1643
R4687 VSS.n536 VSS.t472 0.1643
R4688 VSS.n537 VSS.t476 0.1643
R4689 VSS.n537 VSS.t478 0.1643
R4690 VSS.n539 VSS.t470 0.1643
R4691 VSS.n539 VSS.t474 0.1643
R4692 VSS.n541 VSS.t468 0.1643
R4693 VSS.n541 VSS.t456 0.1643
R4694 VSS.n543 VSS.t458 0.1643
R4695 VSS.n543 VSS.t466 0.1643
R4696 VSS.n545 VSS.t462 0.1643
R4697 VSS.n545 VSS.t464 0.1643
R4698 VSS.n547 VSS.t454 0.1643
R4699 VSS.n547 VSS.t460 0.1643
R4700 VSS.n582 VSS.t438 0.1643
R4701 VSS.n582 VSS.t452 0.1643
R4702 VSS.n589 VSS.t449 0.1643
R4703 VSS.n589 VSS.t450 0.1643
R4704 VSS.n587 VSS.t448 0.1643
R4705 VSS.n587 VSS.t440 0.1643
R4706 VSS.n585 VSS.t444 0.1643
R4707 VSS.n585 VSS.t446 0.1643
R4708 VSS.n584 VSS.t436 0.1643
R4709 VSS.n584 VSS.t442 0.1643
R4710 VSS.n833 VSS.t305 0.1643
R4711 VSS.n833 VSS.t301 0.1643
R4712 VSS.n834 VSS.t307 0.1643
R4713 VSS.n834 VSS.t303 0.1643
R4714 VSS.n836 VSS.t311 0.1643
R4715 VSS.n836 VSS.t313 0.1643
R4716 VSS.n838 VSS.t308 0.1643
R4717 VSS.n838 VSS.t309 0.1643
R4718 VSS.n889 VSS.t297 0.1643
R4719 VSS.n889 VSS.t299 0.1643
R4720 VSS.n887 VSS.t293 0.1643
R4721 VSS.n887 VSS.t295 0.1643
R4722 VSS.n885 VSS.t291 0.1643
R4723 VSS.n885 VSS.t283 0.1643
R4724 VSS.n883 VSS.t287 0.1643
R4725 VSS.n883 VSS.t289 0.1643
R4726 VSS.n881 VSS.t281 0.1643
R4727 VSS.n881 VSS.t285 0.1643
R4728 VSS.n879 VSS.t269 0.1643
R4729 VSS.n879 VSS.t279 0.1643
R4730 VSS.n877 VSS.t275 0.1643
R4731 VSS.n877 VSS.t277 0.1643
R4732 VSS.n876 VSS.t271 0.1643
R4733 VSS.n876 VSS.t273 0.1643
R4734 VSS.n845 VSS.t222 0.1643
R4735 VSS.n845 VSS.t224 0.1643
R4736 VSS.n844 VSS.t220 0.1643
R4737 VSS.n844 VSS.t218 0.1643
R4738 VSS.n639 VSS.t490 0.1643
R4739 VSS.n639 VSS.t492 0.1643
R4740 VSS.n641 VSS.t489 0.1643
R4741 VSS.n641 VSS.t488 0.1643
R4742 VSS.n438 VSS.t496 0.1643
R4743 VSS.n438 VSS.t497 0.1643
R4744 VSS.n439 VSS.t494 0.1643
R4745 VSS.n439 VSS.t495 0.1643
R4746 VSS.n992 VSS.n2 0.144074
R4747 VSS.n441 VSS.n440 0.118945
R4748 VSS.n591 VSS.n583 0.118921
R4749 VSS.n891 VSS.n890 0.118921
R4750 VSS.n642 VSS.n640 0.117954
R4751 VSS.n593 VSS.n592 0.1055
R4752 VSS.n892 VSS.n832 0.1055
R4753 VSS.n580 VSS.n535 0.0755
R4754 VSS.n875 VSS.n841 0.0755
R4755 VSS.n591 VSS.n590 0.0715526
R4756 VSS.n891 VSS.n839 0.0715526
R4757 VSS.n607 VSS.n530 0.0605
R4758 VSS.n902 VSS.n898 0.0605
R4759 VSS.n502 VSS.n489 0.0545
R4760 VSS.n484 VSS.n471 0.0545
R4761 VSS.n551 VSS.n550 0.0478684
R4762 VSS.n847 VSS.n846 0.0478684
R4763 VSS VSS.n994 0.0455
R4764 VSS.n513 VSS.n503 0.0365
R4765 VSS.n470 VSS.n460 0.0365
R4766 VSS.n596 VSS.n532 0.0155
R4767 VSS.n593 VSS.n535 0.0155
R4768 VSS.n841 VSS.n832 0.0155
R4769 VSS.n894 VSS.n893 0.0155
R4770 a_n6400_n23452.n1 a_n6400_n23452.t0 16.0839
R4771 a_n6400_n23452.n1 a_n6400_n23452.n0 12.3065
R4772 a_n6400_n23452.n2 a_n6400_n23452.n1 10.9378
R4773 a_n6400_n23452.n0 a_n6400_n23452.t3 0.1825
R4774 a_n6400_n23452.n0 a_n6400_n23452.t4 0.1825
R4775 a_n6400_n23452.n2 a_n6400_n23452.t2 0.1643
R4776 a_n6400_n23452.t1 a_n6400_n23452.n2 0.1643
R4777 a_n7157_n23500.n1 a_n7157_n23500.t0 16.0839
R4778 a_n7157_n23500.n0 a_n7157_n23500.t2 6.66284
R4779 a_n7157_n23500.t3 a_n7157_n23500.n2 6.62866
R4780 a_n7157_n23500.n0 a_n7157_n23500.t1 6.45713
R4781 a_n7157_n23500.n2 a_n7157_n23500.t4 6.42295
R4782 a_n7157_n23500.n1 a_n7157_n23500.n0 5.97129
R4783 a_n7157_n23500.n2 a_n7157_n23500.n1 4.55024
R4784 a_n10800_n23372.n0 a_n10800_n23372.t3 139.69
R4785 a_n10800_n23372.n0 a_n10800_n23372.t2 139.69
R4786 a_n10800_n23372.n1 a_n10800_n23372.n0 36.7175
R4787 a_n10800_n23372.n1 a_n10800_n23372.t1 14.2148
R4788 a_n10800_n23372.t0 a_n10800_n23372.n1 11.6368
R4789 a_n6400_n21652.n1 a_n6400_n21652.t2 16.0839
R4790 a_n6400_n21652.n2 a_n6400_n21652.n1 12.3065
R4791 a_n6400_n21652.n1 a_n6400_n21652.n0 10.9378
R4792 a_n6400_n21652.n2 a_n6400_n21652.t1 0.1825
R4793 a_n6400_n21652.t0 a_n6400_n21652.n2 0.1825
R4794 a_n6400_n21652.n0 a_n6400_n21652.t4 0.1643
R4795 a_n6400_n21652.n0 a_n6400_n21652.t3 0.1643
R4796 a_n7157_n21700.n1 a_n7157_n21700.t0 16.0839
R4797 a_n7157_n21700.n0 a_n7157_n21700.t4 6.66284
R4798 a_n7157_n21700.n2 a_n7157_n21700.t1 6.62866
R4799 a_n7157_n21700.n0 a_n7157_n21700.t3 6.45713
R4800 a_n7157_n21700.t2 a_n7157_n21700.n2 6.42295
R4801 a_n7157_n21700.n1 a_n7157_n21700.n0 5.97129
R4802 a_n7157_n21700.n2 a_n7157_n21700.n1 4.55024
R4803 a_n10800_n21572.n0 a_n10800_n21572.t3 139.69
R4804 a_n10800_n21572.n0 a_n10800_n21572.t2 139.69
R4805 a_n10800_n21572.n1 a_n10800_n21572.n0 36.7175
R4806 a_n10800_n21572.n1 a_n10800_n21572.t1 14.2148
R4807 a_n10800_n21572.t0 a_n10800_n21572.n1 11.6368
R4808 a_n6400_n19852.n1 a_n6400_n19852.t2 16.1006
R4809 a_n6400_n19852.n2 a_n6400_n19852.n1 12.3065
R4810 a_n6400_n19852.n1 a_n6400_n19852.n0 10.9378
R4811 a_n6400_n19852.n2 a_n6400_n19852.t1 0.1825
R4812 a_n6400_n19852.t0 a_n6400_n19852.n2 0.1825
R4813 a_n6400_n19852.n0 a_n6400_n19852.t4 0.1643
R4814 a_n6400_n19852.n0 a_n6400_n19852.t3 0.1643
R4815 a_n7300_n19900.n1 a_n7300_n19900.t4 16.1006
R4816 a_n7300_n19900.n0 a_n7300_n19900.t3 6.66284
R4817 a_n7300_n19900.n2 a_n7300_n19900.t0 6.62866
R4818 a_n7300_n19900.n0 a_n7300_n19900.t2 6.45713
R4819 a_n7300_n19900.t1 a_n7300_n19900.n2 6.42295
R4820 a_n7300_n19900.n1 a_n7300_n19900.n0 5.97129
R4821 a_n7300_n19900.n2 a_n7300_n19900.n1 4.55024
R4822 a_n10800_n19772.n0 a_n10800_n19772.t3 139.69
R4823 a_n10800_n19772.n0 a_n10800_n19772.t2 139.69
R4824 a_n10800_n19772.n1 a_n10800_n19772.n0 36.7175
R4825 a_n10800_n19772.n1 a_n10800_n19772.t1 14.2148
R4826 a_n10800_n19772.t0 a_n10800_n19772.n1 11.6368
R4827 a_n6400_n18052.n1 a_n6400_n18052.t4 16.1006
R4828 a_n6400_n18052.n2 a_n6400_n18052.n1 12.3065
R4829 a_n6400_n18052.n1 a_n6400_n18052.n0 10.9378
R4830 a_n6400_n18052.t0 a_n6400_n18052.n2 0.1825
R4831 a_n6400_n18052.n2 a_n6400_n18052.t1 0.1825
R4832 a_n6400_n18052.n0 a_n6400_n18052.t3 0.1643
R4833 a_n6400_n18052.n0 a_n6400_n18052.t2 0.1643
R4834 a_n7300_n18100.n1 a_n7300_n18100.t4 16.1006
R4835 a_n7300_n18100.n0 a_n7300_n18100.t3 6.66284
R4836 a_n7300_n18100.n2 a_n7300_n18100.t0 6.62866
R4837 a_n7300_n18100.n0 a_n7300_n18100.t2 6.45713
R4838 a_n7300_n18100.t1 a_n7300_n18100.n2 6.42295
R4839 a_n7300_n18100.n1 a_n7300_n18100.n0 5.97129
R4840 a_n7300_n18100.n2 a_n7300_n18100.n1 4.55024
R4841 a_n10800_n17972.n0 a_n10800_n17972.t3 139.69
R4842 a_n10800_n17972.n0 a_n10800_n17972.t2 139.69
R4843 a_n10800_n17972.n1 a_n10800_n17972.n0 36.7175
R4844 a_n10800_n17972.n1 a_n10800_n17972.t1 14.2148
R4845 a_n10800_n17972.t0 a_n10800_n17972.n1 11.6368
R4846 a_n6400_n16252.n1 a_n6400_n16252.t0 16.1006
R4847 a_n6400_n16252.n1 a_n6400_n16252.n0 12.3065
R4848 a_n6400_n16252.n2 a_n6400_n16252.n1 10.9378
R4849 a_n6400_n16252.n0 a_n6400_n16252.t4 0.1825
R4850 a_n6400_n16252.n0 a_n6400_n16252.t3 0.1825
R4851 a_n6400_n16252.n2 a_n6400_n16252.t2 0.1643
R4852 a_n6400_n16252.t1 a_n6400_n16252.n2 0.1643
R4853 a_n7300_n16300.n1 a_n7300_n16300.t2 16.1006
R4854 a_n7300_n16300.n0 a_n7300_n16300.t1 6.66284
R4855 a_n7300_n16300.t3 a_n7300_n16300.n2 6.62866
R4856 a_n7300_n16300.n0 a_n7300_n16300.t0 6.45713
R4857 a_n7300_n16300.n2 a_n7300_n16300.t4 6.42295
R4858 a_n7300_n16300.n1 a_n7300_n16300.n0 5.97129
R4859 a_n7300_n16300.n2 a_n7300_n16300.n1 4.55024
R4860 a_n10800_n16172.n0 a_n10800_n16172.t3 139.69
R4861 a_n10800_n16172.n0 a_n10800_n16172.t2 139.69
R4862 a_n10800_n16172.n1 a_n10800_n16172.n0 36.7175
R4863 a_n10800_n16172.n1 a_n10800_n16172.t1 14.2148
R4864 a_n10800_n16172.t0 a_n10800_n16172.n1 11.6368
R4865 a_n6400_n14452.n1 a_n6400_n14452.t0 16.1006
R4866 a_n6400_n14452.n1 a_n6400_n14452.n0 12.3065
R4867 a_n6400_n14452.n2 a_n6400_n14452.n1 10.9378
R4868 a_n6400_n14452.n0 a_n6400_n14452.t3 0.1825
R4869 a_n6400_n14452.n0 a_n6400_n14452.t2 0.1825
R4870 a_n6400_n14452.t1 a_n6400_n14452.n2 0.1643
R4871 a_n6400_n14452.n2 a_n6400_n14452.t4 0.1643
R4872 a_n7300_n14500.n1 a_n7300_n14500.t3 16.1006
R4873 a_n7300_n14500.n0 a_n7300_n14500.t0 6.66284
R4874 a_n7300_n14500.n2 a_n7300_n14500.t1 6.62866
R4875 a_n7300_n14500.n0 a_n7300_n14500.t4 6.45713
R4876 a_n7300_n14500.t2 a_n7300_n14500.n2 6.42295
R4877 a_n7300_n14500.n1 a_n7300_n14500.n0 5.97129
R4878 a_n7300_n14500.n2 a_n7300_n14500.n1 4.55024
R4879 a_n10800_n14372.n0 a_n10800_n14372.t3 139.69
R4880 a_n10800_n14372.n0 a_n10800_n14372.t2 139.69
R4881 a_n10800_n14372.n1 a_n10800_n14372.n0 36.7175
R4882 a_n10800_n14372.n1 a_n10800_n14372.t1 14.2148
R4883 a_n10800_n14372.t0 a_n10800_n14372.n1 11.6368
R4884 a_n6400_n12652.n1 a_n6400_n12652.t4 16.1006
R4885 a_n6400_n12652.n2 a_n6400_n12652.n1 12.3065
R4886 a_n6400_n12652.n1 a_n6400_n12652.n0 10.9378
R4887 a_n6400_n12652.t0 a_n6400_n12652.n2 0.1825
R4888 a_n6400_n12652.n2 a_n6400_n12652.t1 0.1825
R4889 a_n6400_n12652.n0 a_n6400_n12652.t3 0.1643
R4890 a_n6400_n12652.n0 a_n6400_n12652.t2 0.1643
R4891 a_n7300_n12700.n1 a_n7300_n12700.t4 16.1006
R4892 a_n7300_n12700.n0 a_n7300_n12700.t3 6.66284
R4893 a_n7300_n12700.n2 a_n7300_n12700.t0 6.62866
R4894 a_n7300_n12700.n0 a_n7300_n12700.t2 6.45713
R4895 a_n7300_n12700.t1 a_n7300_n12700.n2 6.42295
R4896 a_n7300_n12700.n1 a_n7300_n12700.n0 5.97129
R4897 a_n7300_n12700.n2 a_n7300_n12700.n1 4.55024
R4898 a_n10800_n12572.n0 a_n10800_n12572.t3 139.69
R4899 a_n10800_n12572.n0 a_n10800_n12572.t2 139.69
R4900 a_n10800_n12572.n1 a_n10800_n12572.n0 36.7175
R4901 a_n10800_n12572.n1 a_n10800_n12572.t1 14.2148
R4902 a_n10800_n12572.t0 a_n10800_n12572.n1 11.6368
R4903 a_2148_n500.n5 a_2148_n500.n3 10.5451
R4904 a_2148_n500.n5 a_2148_n500.n4 10.5451
R4905 a_2148_n500.n2 a_2148_n500.t4 6.45713
R4906 a_2148_n500.n8 a_2148_n500.n7 6.38754
R4907 a_2148_n500.n1 a_2148_n500.n0 6.29333
R4908 a_2148_n500.n6 a_2148_n500.n2 4.68405
R4909 a_2148_n500.n7 a_2148_n500.n6 2.22659
R4910 a_2148_n500.n6 a_2148_n500.n5 0.8055
R4911 a_2148_n500.n3 a_2148_n500.t0 0.3281
R4912 a_2148_n500.n3 a_2148_n500.t1 0.3281
R4913 a_2148_n500.n4 a_2148_n500.t2 0.3281
R4914 a_2148_n500.n4 a_2148_n500.t3 0.3281
R4915 a_2148_n500.n2 a_2148_n500.n1 0.189974
R4916 a_2148_n500.t7 a_2148_n500.n8 0.1643
R4917 a_2148_n500.n8 a_2148_n500.t8 0.1643
R4918 a_2148_n500.n0 a_2148_n500.t5 0.1643
R4919 a_2148_n500.n0 a_2148_n500.t6 0.1643
R4920 a_2148_n500.n7 a_2148_n500.n1 0.0928953
R4921 a_n5052_n1000.n5 a_n5052_n1000.n3 11.1933
R4922 a_n5052_n1000.n5 a_n5052_n1000.n4 11.1933
R4923 a_n5052_n1000.n2 a_n5052_n1000.t4 6.45713
R4924 a_n5052_n1000.n8 a_n5052_n1000.n7 6.38754
R4925 a_n5052_n1000.n1 a_n5052_n1000.n0 6.29333
R4926 a_n5052_n1000.n6 a_n5052_n1000.n2 4.68405
R4927 a_n5052_n1000.n7 a_n5052_n1000.n6 2.22659
R4928 a_n5052_n1000.n6 a_n5052_n1000.n5 0.5555
R4929 a_n5052_n1000.n2 a_n5052_n1000.n1 0.189974
R4930 a_n5052_n1000.t7 a_n5052_n1000.n8 0.1643
R4931 a_n5052_n1000.n8 a_n5052_n1000.t8 0.1643
R4932 a_n5052_n1000.n0 a_n5052_n1000.t5 0.1643
R4933 a_n5052_n1000.n0 a_n5052_n1000.t6 0.1643
R4934 a_n5052_n1000.n3 a_n5052_n1000.t1 0.1643
R4935 a_n5052_n1000.n3 a_n5052_n1000.t0 0.1643
R4936 a_n5052_n1000.n4 a_n5052_n1000.t3 0.1643
R4937 a_n5052_n1000.n4 a_n5052_n1000.t2 0.1643
R4938 a_n5052_n1000.n7 a_n5052_n1000.n1 0.0928953
R4939 a_n5052_2600.n3 a_n5052_2600.t7 7.27134
R4940 a_n5052_2600.n3 a_n5052_2600.t4 7.27134
R4941 a_n5052_2600.n2 a_n5052_2600.n0 6.71615
R4942 a_n5052_2600.n2 a_n5052_2600.n1 6.71615
R4943 a_n5052_2600.n4 a_n5052_2600.n3 6.31615
R4944 a_n5052_2600.n4 a_n5052_2600.t5 0.8195
R4945 a_n5052_2600.t6 a_n5052_2600.n4 0.8195
R4946 a_n5052_2600.n0 a_n5052_2600.t2 0.8195
R4947 a_n5052_2600.n0 a_n5052_2600.t3 0.8195
R4948 a_n5052_2600.n1 a_n5052_2600.t0 0.8195
R4949 a_n5052_2600.n1 a_n5052_2600.t1 0.8195
R4950 a_n5052_2600.n3 a_n5052_2600.n2 0.3955
R4951 a_5300_5958.t1 a_5300_5958.t0 26.7478
R4952 a_484_3500.t0 a_484_3500.t1 26.7478
R4953 a_n1900_5958.t0 a_n1900_5958.t1 26.7478
R4954 a_n3600_5641.n3 a_n3600_5641.t6 74.5091
R4955 a_n3600_5641.n3 a_n3600_5641.t7 74.5091
R4956 a_n3600_5641.n4 a_n3600_5641.n3 37.8057
R4957 a_n3600_5641.n1 a_n3600_5641.t2 13.0154
R4958 a_n3600_5641.n1 a_n3600_5641.t3 10.6142
R4959 a_n3600_5641.n0 a_n3600_5641.t4 7.23009
R4960 a_n3600_5641.n0 a_n3600_5641.t5 7.22685
R4961 a_n3600_5641.n5 a_n3600_5641.t0 6.55206
R4962 a_n3600_5641.t1 a_n3600_5641.n5 6.54882
R4963 a_n3600_5641.n5 a_n3600_5641.n4 2.75982
R4964 a_n3600_5641.n2 a_n3600_5641.n0 2.26891
R4965 a_n3600_5641.n2 a_n3600_5641.n1 0.425955
R4966 a_n3600_5641.n4 a_n3600_5641.n2 0.393227
R4967 a_n6572_3500.n3 a_n6572_3500.t6 74.5091
R4968 a_n6572_3500.n3 a_n6572_3500.t7 74.5091
R4969 a_n6572_3500.n4 a_n6572_3500.n3 37.5518
R4970 a_n6572_3500.n1 a_n6572_3500.t2 13.0154
R4971 a_n6572_3500.n1 a_n6572_3500.t3 10.6142
R4972 a_n6572_3500.n0 a_n6572_3500.t1 7.23009
R4973 a_n6572_3500.n0 a_n6572_3500.t0 7.22685
R4974 a_n6572_3500.t5 a_n6572_3500.n5 6.55206
R4975 a_n6572_3500.n5 a_n6572_3500.t4 6.54882
R4976 a_n6572_3500.n5 a_n6572_3500.n4 2.59618
R4977 a_n6572_3500.n2 a_n6572_3500.n0 2.26891
R4978 a_n6572_3500.n4 a_n6572_3500.n2 0.556864
R4979 a_n6572_3500.n2 a_n6572_3500.n1 0.425955
R4980 a_n6716_3500.t1 a_n6716_3500.t0 26.7478
R4981 XFRONT.XFE_O.NTAIL.n29 XFRONT.XFE_O.NTAIL.n22 13.0309
R4982 XFRONT.XFE_O.NTAIL.n29 XFRONT.XFE_O.NTAIL.n28 11.5048
R4983 XFRONT.XFE_O.NTAIL.n41 XFRONT.XFE_O.NTAIL.n40 11.5048
R4984 XFRONT.XFE_O.NTAIL.n34 XFRONT.XFE_O.NTAIL.n33 9.03963
R4985 XFRONT.XFE_O.NTAIL.n1 XFRONT.XFE_O.NTAIL.t36 5.82877
R4986 XFRONT.XFE_O.NTAIL.n13 XFRONT.XFE_O.NTAIL.t13 5.82877
R4987 XFRONT.XFE_O.NTAIL.n33 XFRONT.XFE_O.NTAIL.t0 5.78141
R4988 XFRONT.XFE_O.NTAIL.n32 XFRONT.XFE_O.NTAIL.n30 5.66497
R4989 XFRONT.XFE_O.NTAIL.n28 XFRONT.XFE_O.NTAIL.n23 5.57485
R4990 XFRONT.XFE_O.NTAIL.n27 XFRONT.XFE_O.NTAIL.n25 5.57485
R4991 XFRONT.XFE_O.NTAIL.n40 XFRONT.XFE_O.NTAIL.n35 5.57485
R4992 XFRONT.XFE_O.NTAIL.n39 XFRONT.XFE_O.NTAIL.n37 5.57485
R4993 XFRONT.XFE_O.NTAIL.n32 XFRONT.XFE_O.NTAIL.n31 5.4755
R4994 XFRONT.XFE_O.NTAIL.n1 XFRONT.XFE_O.NTAIL.n0 5.4755
R4995 XFRONT.XFE_O.NTAIL.n3 XFRONT.XFE_O.NTAIL.n2 5.4755
R4996 XFRONT.XFE_O.NTAIL.n5 XFRONT.XFE_O.NTAIL.n4 5.4755
R4997 XFRONT.XFE_O.NTAIL.n7 XFRONT.XFE_O.NTAIL.n6 5.4755
R4998 XFRONT.XFE_O.NTAIL.n9 XFRONT.XFE_O.NTAIL.n8 5.4755
R4999 XFRONT.XFE_O.NTAIL.n11 XFRONT.XFE_O.NTAIL.n10 5.4755
R5000 XFRONT.XFE_O.NTAIL.n21 XFRONT.XFE_O.NTAIL.n20 5.4755
R5001 XFRONT.XFE_O.NTAIL.n19 XFRONT.XFE_O.NTAIL.n18 5.4755
R5002 XFRONT.XFE_O.NTAIL.n17 XFRONT.XFE_O.NTAIL.n16 5.4755
R5003 XFRONT.XFE_O.NTAIL.n15 XFRONT.XFE_O.NTAIL.n14 5.4755
R5004 XFRONT.XFE_O.NTAIL.n13 XFRONT.XFE_O.NTAIL.n12 5.4755
R5005 XFRONT.XFE_O.NTAIL.n28 XFRONT.XFE_O.NTAIL.n24 5.38537
R5006 XFRONT.XFE_O.NTAIL.n27 XFRONT.XFE_O.NTAIL.n26 5.38537
R5007 XFRONT.XFE_O.NTAIL.n40 XFRONT.XFE_O.NTAIL.n36 5.38537
R5008 XFRONT.XFE_O.NTAIL.n39 XFRONT.XFE_O.NTAIL.n38 5.38537
R5009 XFRONT.XFE_O.NTAIL.n34 XFRONT.XFE_O.NTAIL.n29 2.27007
R5010 XFRONT.XFE_O.NTAIL.n41 XFRONT.XFE_O.NTAIL.n34 0.86137
R5011 XFRONT.XFE_O.NTAIL.n23 XFRONT.XFE_O.NTAIL.t41 0.20525
R5012 XFRONT.XFE_O.NTAIL.n23 XFRONT.XFE_O.NTAIL.t42 0.20525
R5013 XFRONT.XFE_O.NTAIL.n24 XFRONT.XFE_O.NTAIL.t43 0.20525
R5014 XFRONT.XFE_O.NTAIL.n24 XFRONT.XFE_O.NTAIL.t44 0.20525
R5015 XFRONT.XFE_O.NTAIL.n26 XFRONT.XFE_O.NTAIL.t38 0.20525
R5016 XFRONT.XFE_O.NTAIL.n26 XFRONT.XFE_O.NTAIL.t39 0.20525
R5017 XFRONT.XFE_O.NTAIL.n25 XFRONT.XFE_O.NTAIL.t40 0.20525
R5018 XFRONT.XFE_O.NTAIL.n25 XFRONT.XFE_O.NTAIL.t37 0.20525
R5019 XFRONT.XFE_O.NTAIL.n35 XFRONT.XFE_O.NTAIL.t9 0.20525
R5020 XFRONT.XFE_O.NTAIL.n35 XFRONT.XFE_O.NTAIL.t5 0.20525
R5021 XFRONT.XFE_O.NTAIL.n36 XFRONT.XFE_O.NTAIL.t7 0.20525
R5022 XFRONT.XFE_O.NTAIL.n36 XFRONT.XFE_O.NTAIL.t8 0.20525
R5023 XFRONT.XFE_O.NTAIL.n38 XFRONT.XFE_O.NTAIL.t12 0.20525
R5024 XFRONT.XFE_O.NTAIL.n38 XFRONT.XFE_O.NTAIL.t6 0.20525
R5025 XFRONT.XFE_O.NTAIL.n37 XFRONT.XFE_O.NTAIL.t10 0.20525
R5026 XFRONT.XFE_O.NTAIL.n37 XFRONT.XFE_O.NTAIL.t11 0.20525
R5027 XFRONT.XFE_O.NTAIL.n15 XFRONT.XFE_O.NTAIL.n13 0.189974
R5028 XFRONT.XFE_O.NTAIL.n17 XFRONT.XFE_O.NTAIL.n15 0.189974
R5029 XFRONT.XFE_O.NTAIL.n19 XFRONT.XFE_O.NTAIL.n17 0.189974
R5030 XFRONT.XFE_O.NTAIL.n21 XFRONT.XFE_O.NTAIL.n19 0.189974
R5031 XFRONT.XFE_O.NTAIL.n11 XFRONT.XFE_O.NTAIL.n9 0.189974
R5032 XFRONT.XFE_O.NTAIL.n9 XFRONT.XFE_O.NTAIL.n7 0.189974
R5033 XFRONT.XFE_O.NTAIL.n7 XFRONT.XFE_O.NTAIL.n5 0.189974
R5034 XFRONT.XFE_O.NTAIL.n5 XFRONT.XFE_O.NTAIL.n3 0.189974
R5035 XFRONT.XFE_O.NTAIL.n3 XFRONT.XFE_O.NTAIL.n1 0.189974
R5036 XFRONT.XFE_O.NTAIL.n28 XFRONT.XFE_O.NTAIL.n27 0.189974
R5037 XFRONT.XFE_O.NTAIL.n40 XFRONT.XFE_O.NTAIL.n39 0.189974
R5038 XFRONT.XFE_O.NTAIL.n30 XFRONT.XFE_O.NTAIL.t3 0.1643
R5039 XFRONT.XFE_O.NTAIL.n30 XFRONT.XFE_O.NTAIL.t4 0.1643
R5040 XFRONT.XFE_O.NTAIL.n31 XFRONT.XFE_O.NTAIL.t1 0.1643
R5041 XFRONT.XFE_O.NTAIL.n31 XFRONT.XFE_O.NTAIL.t2 0.1643
R5042 XFRONT.XFE_O.NTAIL.n0 XFRONT.XFE_O.NTAIL.t34 0.1643
R5043 XFRONT.XFE_O.NTAIL.n0 XFRONT.XFE_O.NTAIL.t35 0.1643
R5044 XFRONT.XFE_O.NTAIL.n2 XFRONT.XFE_O.NTAIL.t32 0.1643
R5045 XFRONT.XFE_O.NTAIL.n2 XFRONT.XFE_O.NTAIL.t33 0.1643
R5046 XFRONT.XFE_O.NTAIL.n4 XFRONT.XFE_O.NTAIL.t30 0.1643
R5047 XFRONT.XFE_O.NTAIL.n4 XFRONT.XFE_O.NTAIL.t31 0.1643
R5048 XFRONT.XFE_O.NTAIL.n6 XFRONT.XFE_O.NTAIL.t28 0.1643
R5049 XFRONT.XFE_O.NTAIL.n6 XFRONT.XFE_O.NTAIL.t29 0.1643
R5050 XFRONT.XFE_O.NTAIL.n8 XFRONT.XFE_O.NTAIL.t26 0.1643
R5051 XFRONT.XFE_O.NTAIL.n8 XFRONT.XFE_O.NTAIL.t27 0.1643
R5052 XFRONT.XFE_O.NTAIL.n10 XFRONT.XFE_O.NTAIL.t24 0.1643
R5053 XFRONT.XFE_O.NTAIL.n10 XFRONT.XFE_O.NTAIL.t25 0.1643
R5054 XFRONT.XFE_O.NTAIL.n20 XFRONT.XFE_O.NTAIL.t22 0.1643
R5055 XFRONT.XFE_O.NTAIL.n20 XFRONT.XFE_O.NTAIL.t23 0.1643
R5056 XFRONT.XFE_O.NTAIL.n18 XFRONT.XFE_O.NTAIL.t20 0.1643
R5057 XFRONT.XFE_O.NTAIL.n18 XFRONT.XFE_O.NTAIL.t21 0.1643
R5058 XFRONT.XFE_O.NTAIL.n16 XFRONT.XFE_O.NTAIL.t18 0.1643
R5059 XFRONT.XFE_O.NTAIL.n16 XFRONT.XFE_O.NTAIL.t19 0.1643
R5060 XFRONT.XFE_O.NTAIL.n14 XFRONT.XFE_O.NTAIL.t16 0.1643
R5061 XFRONT.XFE_O.NTAIL.n14 XFRONT.XFE_O.NTAIL.t17 0.1643
R5062 XFRONT.XFE_O.NTAIL.n12 XFRONT.XFE_O.NTAIL.t14 0.1643
R5063 XFRONT.XFE_O.NTAIL.n12 XFRONT.XFE_O.NTAIL.t15 0.1643
R5064 XFRONT.XFE_O.NTAIL.n22 XFRONT.XFE_O.NTAIL.n21 0.0952368
R5065 XFRONT.XFE_O.NTAIL.n22 XFRONT.XFE_O.NTAIL.n11 0.0952368
R5066 XFRONT.XFE_O.NTAIL.n33 XFRONT.XFE_O.NTAIL.n32 0.0478684
R5067 XFRONT.XFE_O.NTAIL XFRONT.XFE_O.NTAIL.n41 0.0396304
R5068 XFRONT.XFE_E.NTAIL.n35 XFRONT.XFE_E.NTAIL.n28 13.0309
R5069 XFRONT.XFE_E.NTAIL XFRONT.XFE_E.NTAIL.n5 11.544
R5070 XFRONT.XFE_E.NTAIL.n35 XFRONT.XFE_E.NTAIL.n34 11.5048
R5071 XFRONT.XFE_E.NTAIL.n40 XFRONT.XFE_E.NTAIL.n39 9.03963
R5072 XFRONT.XFE_E.NTAIL.n7 XFRONT.XFE_E.NTAIL.t44 5.82877
R5073 XFRONT.XFE_E.NTAIL.n17 XFRONT.XFE_E.NTAIL.t21 5.82877
R5074 XFRONT.XFE_E.NTAIL.n39 XFRONT.XFE_E.NTAIL.t4 5.78141
R5075 XFRONT.XFE_E.NTAIL.n38 XFRONT.XFE_E.NTAIL.n36 5.66497
R5076 XFRONT.XFE_E.NTAIL.n2 XFRONT.XFE_E.NTAIL.n0 5.57485
R5077 XFRONT.XFE_E.NTAIL.n5 XFRONT.XFE_E.NTAIL.n4 5.57485
R5078 XFRONT.XFE_E.NTAIL.n31 XFRONT.XFE_E.NTAIL.n29 5.57485
R5079 XFRONT.XFE_E.NTAIL.n34 XFRONT.XFE_E.NTAIL.n33 5.57485
R5080 XFRONT.XFE_E.NTAIL.n7 XFRONT.XFE_E.NTAIL.n6 5.4755
R5081 XFRONT.XFE_E.NTAIL.n38 XFRONT.XFE_E.NTAIL.n37 5.4755
R5082 XFRONT.XFE_E.NTAIL.n9 XFRONT.XFE_E.NTAIL.n8 5.4755
R5083 XFRONT.XFE_E.NTAIL.n11 XFRONT.XFE_E.NTAIL.n10 5.4755
R5084 XFRONT.XFE_E.NTAIL.n13 XFRONT.XFE_E.NTAIL.n12 5.4755
R5085 XFRONT.XFE_E.NTAIL.n15 XFRONT.XFE_E.NTAIL.n14 5.4755
R5086 XFRONT.XFE_E.NTAIL.n27 XFRONT.XFE_E.NTAIL.n26 5.4755
R5087 XFRONT.XFE_E.NTAIL.n25 XFRONT.XFE_E.NTAIL.n24 5.4755
R5088 XFRONT.XFE_E.NTAIL.n23 XFRONT.XFE_E.NTAIL.n22 5.4755
R5089 XFRONT.XFE_E.NTAIL.n21 XFRONT.XFE_E.NTAIL.n20 5.4755
R5090 XFRONT.XFE_E.NTAIL.n19 XFRONT.XFE_E.NTAIL.n18 5.4755
R5091 XFRONT.XFE_E.NTAIL.n17 XFRONT.XFE_E.NTAIL.n16 5.4755
R5092 XFRONT.XFE_E.NTAIL.n2 XFRONT.XFE_E.NTAIL.n1 5.38537
R5093 XFRONT.XFE_E.NTAIL.n5 XFRONT.XFE_E.NTAIL.n3 5.38537
R5094 XFRONT.XFE_E.NTAIL.n31 XFRONT.XFE_E.NTAIL.n30 5.38537
R5095 XFRONT.XFE_E.NTAIL.n34 XFRONT.XFE_E.NTAIL.n32 5.38537
R5096 XFRONT.XFE_E.NTAIL.n40 XFRONT.XFE_E.NTAIL.n35 2.27007
R5097 XFRONT.XFE_E.NTAIL XFRONT.XFE_E.NTAIL.n40 0.822239
R5098 XFRONT.XFE_E.NTAIL.n0 XFRONT.XFE_E.NTAIL.t19 0.20525
R5099 XFRONT.XFE_E.NTAIL.n0 XFRONT.XFE_E.NTAIL.t20 0.20525
R5100 XFRONT.XFE_E.NTAIL.n1 XFRONT.XFE_E.NTAIL.t15 0.20525
R5101 XFRONT.XFE_E.NTAIL.n1 XFRONT.XFE_E.NTAIL.t16 0.20525
R5102 XFRONT.XFE_E.NTAIL.n3 XFRONT.XFE_E.NTAIL.t13 0.20525
R5103 XFRONT.XFE_E.NTAIL.n3 XFRONT.XFE_E.NTAIL.t14 0.20525
R5104 XFRONT.XFE_E.NTAIL.n4 XFRONT.XFE_E.NTAIL.t17 0.20525
R5105 XFRONT.XFE_E.NTAIL.n4 XFRONT.XFE_E.NTAIL.t18 0.20525
R5106 XFRONT.XFE_E.NTAIL.n29 XFRONT.XFE_E.NTAIL.t8 0.20525
R5107 XFRONT.XFE_E.NTAIL.n29 XFRONT.XFE_E.NTAIL.t9 0.20525
R5108 XFRONT.XFE_E.NTAIL.n30 XFRONT.XFE_E.NTAIL.t6 0.20525
R5109 XFRONT.XFE_E.NTAIL.n30 XFRONT.XFE_E.NTAIL.t7 0.20525
R5110 XFRONT.XFE_E.NTAIL.n32 XFRONT.XFE_E.NTAIL.t12 0.20525
R5111 XFRONT.XFE_E.NTAIL.n32 XFRONT.XFE_E.NTAIL.t5 0.20525
R5112 XFRONT.XFE_E.NTAIL.n33 XFRONT.XFE_E.NTAIL.t10 0.20525
R5113 XFRONT.XFE_E.NTAIL.n33 XFRONT.XFE_E.NTAIL.t11 0.20525
R5114 XFRONT.XFE_E.NTAIL.n19 XFRONT.XFE_E.NTAIL.n17 0.189974
R5115 XFRONT.XFE_E.NTAIL.n21 XFRONT.XFE_E.NTAIL.n19 0.189974
R5116 XFRONT.XFE_E.NTAIL.n23 XFRONT.XFE_E.NTAIL.n21 0.189974
R5117 XFRONT.XFE_E.NTAIL.n25 XFRONT.XFE_E.NTAIL.n23 0.189974
R5118 XFRONT.XFE_E.NTAIL.n27 XFRONT.XFE_E.NTAIL.n25 0.189974
R5119 XFRONT.XFE_E.NTAIL.n15 XFRONT.XFE_E.NTAIL.n13 0.189974
R5120 XFRONT.XFE_E.NTAIL.n13 XFRONT.XFE_E.NTAIL.n11 0.189974
R5121 XFRONT.XFE_E.NTAIL.n11 XFRONT.XFE_E.NTAIL.n9 0.189974
R5122 XFRONT.XFE_E.NTAIL.n9 XFRONT.XFE_E.NTAIL.n7 0.189974
R5123 XFRONT.XFE_E.NTAIL.n5 XFRONT.XFE_E.NTAIL.n2 0.189974
R5124 XFRONT.XFE_E.NTAIL.n34 XFRONT.XFE_E.NTAIL.n31 0.189974
R5125 XFRONT.XFE_E.NTAIL.n6 XFRONT.XFE_E.NTAIL.t42 0.1643
R5126 XFRONT.XFE_E.NTAIL.n6 XFRONT.XFE_E.NTAIL.t43 0.1643
R5127 XFRONT.XFE_E.NTAIL.n37 XFRONT.XFE_E.NTAIL.t2 0.1643
R5128 XFRONT.XFE_E.NTAIL.n37 XFRONT.XFE_E.NTAIL.t3 0.1643
R5129 XFRONT.XFE_E.NTAIL.n36 XFRONT.XFE_E.NTAIL.t0 0.1643
R5130 XFRONT.XFE_E.NTAIL.n36 XFRONT.XFE_E.NTAIL.t1 0.1643
R5131 XFRONT.XFE_E.NTAIL.n8 XFRONT.XFE_E.NTAIL.t40 0.1643
R5132 XFRONT.XFE_E.NTAIL.n8 XFRONT.XFE_E.NTAIL.t41 0.1643
R5133 XFRONT.XFE_E.NTAIL.n10 XFRONT.XFE_E.NTAIL.t38 0.1643
R5134 XFRONT.XFE_E.NTAIL.n10 XFRONT.XFE_E.NTAIL.t39 0.1643
R5135 XFRONT.XFE_E.NTAIL.n12 XFRONT.XFE_E.NTAIL.t36 0.1643
R5136 XFRONT.XFE_E.NTAIL.n12 XFRONT.XFE_E.NTAIL.t37 0.1643
R5137 XFRONT.XFE_E.NTAIL.n14 XFRONT.XFE_E.NTAIL.t34 0.1643
R5138 XFRONT.XFE_E.NTAIL.n14 XFRONT.XFE_E.NTAIL.t35 0.1643
R5139 XFRONT.XFE_E.NTAIL.n26 XFRONT.XFE_E.NTAIL.t32 0.1643
R5140 XFRONT.XFE_E.NTAIL.n26 XFRONT.XFE_E.NTAIL.t33 0.1643
R5141 XFRONT.XFE_E.NTAIL.n24 XFRONT.XFE_E.NTAIL.t30 0.1643
R5142 XFRONT.XFE_E.NTAIL.n24 XFRONT.XFE_E.NTAIL.t31 0.1643
R5143 XFRONT.XFE_E.NTAIL.n22 XFRONT.XFE_E.NTAIL.t28 0.1643
R5144 XFRONT.XFE_E.NTAIL.n22 XFRONT.XFE_E.NTAIL.t29 0.1643
R5145 XFRONT.XFE_E.NTAIL.n20 XFRONT.XFE_E.NTAIL.t26 0.1643
R5146 XFRONT.XFE_E.NTAIL.n20 XFRONT.XFE_E.NTAIL.t27 0.1643
R5147 XFRONT.XFE_E.NTAIL.n18 XFRONT.XFE_E.NTAIL.t24 0.1643
R5148 XFRONT.XFE_E.NTAIL.n18 XFRONT.XFE_E.NTAIL.t25 0.1643
R5149 XFRONT.XFE_E.NTAIL.n16 XFRONT.XFE_E.NTAIL.t22 0.1643
R5150 XFRONT.XFE_E.NTAIL.n16 XFRONT.XFE_E.NTAIL.t23 0.1643
R5151 XFRONT.XFE_E.NTAIL.n28 XFRONT.XFE_E.NTAIL.n27 0.0952368
R5152 XFRONT.XFE_E.NTAIL.n28 XFRONT.XFE_E.NTAIL.n15 0.0952368
R5153 XFRONT.XFE_E.NTAIL.n39 XFRONT.XFE_E.NTAIL.n38 0.0478684
R5154 XFRONT.XFE_O.DN.t13 XFRONT.XFE_O.DN.n10 127.788
R5155 XFRONT.XFE_O.DN.t6 XFRONT.XFE_O.DN.n0 127.776
R5156 XFRONT.XFE_O.DN.n10 XFRONT.XFE_O.DN.t12 127.668
R5157 XFRONT.XFE_O.DN.n9 XFRONT.XFE_O.DN.t11 127.668
R5158 XFRONT.XFE_O.DN.n8 XFRONT.XFE_O.DN.t10 127.668
R5159 XFRONT.XFE_O.DN.n7 XFRONT.XFE_O.DN.t9 127.668
R5160 XFRONT.XFE_O.DN.n6 XFRONT.XFE_O.DN.t8 127.668
R5161 XFRONT.XFE_O.DN.t7 XFRONT.XFE_O.DN.n0 127.668
R5162 XFRONT.XFE_O.DN.n11 XFRONT.XFE_O.DN.t13 113.632
R5163 XFRONT.XFE_O.DN.n1 XFRONT.XFE_O.DN.t6 113.629
R5164 XFRONT.XFE_O.DN.t12 XFRONT.XFE_O.DN.n5 109.174
R5165 XFRONT.XFE_O.DN.n13 XFRONT.XFE_O.DN.t11 109.174
R5166 XFRONT.XFE_O.DN.n14 XFRONT.XFE_O.DN.t10 109.174
R5167 XFRONT.XFE_O.DN.n15 XFRONT.XFE_O.DN.t9 109.174
R5168 XFRONT.XFE_O.DN.n16 XFRONT.XFE_O.DN.t8 109.174
R5169 XFRONT.XFE_O.DN.n3 XFRONT.XFE_O.DN.t7 109.174
R5170 XFRONT.XFE_O.DN.n13 XFRONT.XFE_O.DN.n12 18.4942
R5171 XFRONT.XFE_O.DN.n14 XFRONT.XFE_O.DN.n4 18.4942
R5172 XFRONT.XFE_O.DN.n15 XFRONT.XFE_O.DN.n2 18.4942
R5173 XFRONT.XFE_O.DN.n17 XFRONT.XFE_O.DN.n16 18.4942
R5174 XFRONT.XFE_O.DN.n23 XFRONT.XFE_O.DN.n22 14.1606
R5175 XFRONT.XFE_O.DN.n14 XFRONT.XFE_O.DN.n13 11.6805
R5176 XFRONT.XFE_O.DN.n13 XFRONT.XFE_O.DN.n5 11.6805
R5177 XFRONT.XFE_O.DN.n15 XFRONT.XFE_O.DN.n14 11.6805
R5178 XFRONT.XFE_O.DN.n16 XFRONT.XFE_O.DN.n15 11.6805
R5179 XFRONT.XFE_O.DN.n16 XFRONT.XFE_O.DN.n3 11.6805
R5180 XFRONT.XFE_O.DN.n19 XFRONT.XFE_O.DN.n0 10.8201
R5181 XFRONT.XFE_O.DN.n25 XFRONT.XFE_O.DN.n24 10.5266
R5182 XFRONT.XFE_O.DN.n19 XFRONT.XFE_O.DN.n18 9.02007
R5183 XFRONT.XFE_O.DN.n23 XFRONT.XFE_O.DN.n19 7.2005
R5184 XFRONT.XFE_O.DN.n12 XFRONT.XFE_O.DN.n11 7.17687
R5185 XFRONT.XFE_O.DN.n18 XFRONT.XFE_O.DN.n1 7.05405
R5186 XFRONT.XFE_O.DN.n24 XFRONT.XFE_O.DN.t3 5.7796
R5187 XFRONT.XFE_O.DN.n21 XFRONT.XFE_O.DN.t2 5.73764
R5188 XFRONT.XFE_O.DN.n24 XFRONT.XFE_O.DN.t4 5.59012
R5189 XFRONT.XFE_O.DN.n22 XFRONT.XFE_O.DN.t5 5.54817
R5190 XFRONT.XFE_O.DN.n21 XFRONT.XFE_O.DN.n20 5.32067
R5191 XFRONT.XFE_O.DN.n3 XFRONT.XFE_O.DN.n1 4.4296
R5192 XFRONT.XFE_O.DN.n11 XFRONT.XFE_O.DN.n5 4.42851
R5193 XFRONT.XFE_O.DN.n25 XFRONT.XFE_O.DN.n23 0.978761
R5194 XFRONT.XFE_O.DN.n20 XFRONT.XFE_O.DN.t1 0.228
R5195 XFRONT.XFE_O.DN.n20 XFRONT.XFE_O.DN.t0 0.228
R5196 XFRONT.XFE_O.DN.n22 XFRONT.XFE_O.DN.n21 0.189974
R5197 XFRONT.XFE_O.DN.n10 XFRONT.XFE_O.DN.n9 0.1205
R5198 XFRONT.XFE_O.DN.n9 XFRONT.XFE_O.DN.n8 0.1205
R5199 XFRONT.XFE_O.DN.n8 XFRONT.XFE_O.DN.n7 0.1205
R5200 XFRONT.XFE_O.DN.n7 XFRONT.XFE_O.DN.n6 0.1205
R5201 XFRONT.XFE_O.DN.n12 XFRONT.XFE_O.DN.n4 0.1205
R5202 XFRONT.XFE_O.DN.n4 XFRONT.XFE_O.DN.n2 0.1205
R5203 XFRONT.XFE_O.DN.n17 XFRONT.XFE_O.DN.n2 0.1205
R5204 XFRONT.XFE_O.DN.n6 XFRONT.XFE_O.DN.n0 0.1085
R5205 XFRONT.XFE_O.DN.n18 XFRONT.XFE_O.DN.n17 0.1085
R5206 XFRONT.XFE_O.DN XFRONT.XFE_O.DN.n25 0.0396304
R5207 XFRONT.XFE_O.DP.t13 XFRONT.XFE_O.DP.n15 127.788
R5208 XFRONT.XFE_O.DP.t6 XFRONT.XFE_O.DP.n5 127.776
R5209 XFRONT.XFE_O.DP.n15 XFRONT.XFE_O.DP.t12 127.668
R5210 XFRONT.XFE_O.DP.n14 XFRONT.XFE_O.DP.t11 127.668
R5211 XFRONT.XFE_O.DP.n13 XFRONT.XFE_O.DP.t10 127.668
R5212 XFRONT.XFE_O.DP.n12 XFRONT.XFE_O.DP.t9 127.668
R5213 XFRONT.XFE_O.DP.n11 XFRONT.XFE_O.DP.t8 127.668
R5214 XFRONT.XFE_O.DP.t7 XFRONT.XFE_O.DP.n5 127.668
R5215 XFRONT.XFE_O.DP.n16 XFRONT.XFE_O.DP.t13 113.632
R5216 XFRONT.XFE_O.DP.n6 XFRONT.XFE_O.DP.t6 113.629
R5217 XFRONT.XFE_O.DP.t12 XFRONT.XFE_O.DP.n10 109.174
R5218 XFRONT.XFE_O.DP.n18 XFRONT.XFE_O.DP.t11 109.174
R5219 XFRONT.XFE_O.DP.n19 XFRONT.XFE_O.DP.t10 109.174
R5220 XFRONT.XFE_O.DP.n20 XFRONT.XFE_O.DP.t9 109.174
R5221 XFRONT.XFE_O.DP.n21 XFRONT.XFE_O.DP.t8 109.174
R5222 XFRONT.XFE_O.DP.n8 XFRONT.XFE_O.DP.t7 109.174
R5223 XFRONT.XFE_O.DP.n18 XFRONT.XFE_O.DP.n17 18.4942
R5224 XFRONT.XFE_O.DP.n19 XFRONT.XFE_O.DP.n9 18.4942
R5225 XFRONT.XFE_O.DP.n20 XFRONT.XFE_O.DP.n7 18.4942
R5226 XFRONT.XFE_O.DP.n22 XFRONT.XFE_O.DP.n21 18.4942
R5227 XFRONT.XFE_O.DP.n4 XFRONT.XFE_O.DP.n3 14.5055
R5228 XFRONT.XFE_O.DP.n4 XFRONT.XFE_O.DP.n0 11.7788
R5229 XFRONT.XFE_O.DP.n19 XFRONT.XFE_O.DP.n18 11.6805
R5230 XFRONT.XFE_O.DP.n18 XFRONT.XFE_O.DP.n10 11.6805
R5231 XFRONT.XFE_O.DP.n20 XFRONT.XFE_O.DP.n19 11.6805
R5232 XFRONT.XFE_O.DP.n21 XFRONT.XFE_O.DP.n20 11.6805
R5233 XFRONT.XFE_O.DP.n21 XFRONT.XFE_O.DP.n8 11.6805
R5234 XFRONT.XFE_O.DP.n24 XFRONT.XFE_O.DP.n5 10.8396
R5235 XFRONT.XFE_O.DP.n24 XFRONT.XFE_O.DP.n23 9.0005
R5236 XFRONT.XFE_O.DP.n17 XFRONT.XFE_O.DP.n16 7.17687
R5237 XFRONT.XFE_O.DP.n23 XFRONT.XFE_O.DP.n6 7.05405
R5238 XFRONT.XFE_O.DP.n2 XFRONT.XFE_O.DP.t2 5.73764
R5239 XFRONT.XFE_O.DP.n0 XFRONT.XFE_O.DP.t1 5.70855
R5240 XFRONT.XFE_O.DP.n0 XFRONT.XFE_O.DP.t0 5.66118
R5241 XFRONT.XFE_O.DP.n3 XFRONT.XFE_O.DP.t5 5.54817
R5242 XFRONT.XFE_O.DP.n2 XFRONT.XFE_O.DP.n1 5.32067
R5243 XFRONT.XFE_O.DP.n25 XFRONT.XFE_O.DP.n24 4.75485
R5244 XFRONT.XFE_O.DP.n8 XFRONT.XFE_O.DP.n6 4.4296
R5245 XFRONT.XFE_O.DP.n16 XFRONT.XFE_O.DP.n10 4.42851
R5246 XFRONT.XFE_O.DP.n25 XFRONT.XFE_O.DP.n4 1.8005
R5247 XFRONT.XFE_O.DP.n1 XFRONT.XFE_O.DP.t4 0.228
R5248 XFRONT.XFE_O.DP.n1 XFRONT.XFE_O.DP.t3 0.228
R5249 XFRONT.XFE_O.DP.n3 XFRONT.XFE_O.DP.n2 0.189974
R5250 XFRONT.XFE_O.DP.n15 XFRONT.XFE_O.DP.n14 0.1205
R5251 XFRONT.XFE_O.DP.n14 XFRONT.XFE_O.DP.n13 0.1205
R5252 XFRONT.XFE_O.DP.n13 XFRONT.XFE_O.DP.n12 0.1205
R5253 XFRONT.XFE_O.DP.n12 XFRONT.XFE_O.DP.n11 0.1205
R5254 XFRONT.XFE_O.DP.n17 XFRONT.XFE_O.DP.n9 0.1205
R5255 XFRONT.XFE_O.DP.n9 XFRONT.XFE_O.DP.n7 0.1205
R5256 XFRONT.XFE_O.DP.n22 XFRONT.XFE_O.DP.n7 0.1205
R5257 XFRONT.XFE_O.DP.n11 XFRONT.XFE_O.DP.n5 0.1085
R5258 XFRONT.XFE_O.DP.n23 XFRONT.XFE_O.DP.n22 0.1085
R5259 XFRONT.XFE_O.DP XFRONT.XFE_O.DP.n25 0.0396304
R5260 XFRONT.XFE_E.DP.t6 XFRONT.XFE_E.DP.n7 127.788
R5261 XFRONT.XFE_E.DP.t13 XFRONT.XFE_E.DP.n0 127.776
R5262 XFRONT.XFE_E.DP.t11 XFRONT.XFE_E.DP.n14 127.668
R5263 XFRONT.XFE_E.DP.t12 XFRONT.XFE_E.DP.n0 127.668
R5264 XFRONT.XFE_E.DP.n7 XFRONT.XFE_E.DP.t7 127.668
R5265 XFRONT.XFE_E.DP.t8 XFRONT.XFE_E.DP.n3 127.668
R5266 XFRONT.XFE_E.DP.n12 XFRONT.XFE_E.DP.t9 127.668
R5267 XFRONT.XFE_E.DP.n13 XFRONT.XFE_E.DP.t10 127.668
R5268 XFRONT.XFE_E.DP.n8 XFRONT.XFE_E.DP.t6 113.632
R5269 XFRONT.XFE_E.DP.n17 XFRONT.XFE_E.DP.t13 113.629
R5270 XFRONT.XFE_E.DP.n15 XFRONT.XFE_E.DP.t11 109.174
R5271 XFRONT.XFE_E.DP.n16 XFRONT.XFE_E.DP.t12 109.174
R5272 XFRONT.XFE_E.DP.n9 XFRONT.XFE_E.DP.t7 109.174
R5273 XFRONT.XFE_E.DP.n10 XFRONT.XFE_E.DP.t8 109.174
R5274 XFRONT.XFE_E.DP.t9 XFRONT.XFE_E.DP.n11 109.174
R5275 XFRONT.XFE_E.DP.t10 XFRONT.XFE_E.DP.n2 109.174
R5276 XFRONT.XFE_E.DP.n15 XFRONT.XFE_E.DP.n1 18.4942
R5277 XFRONT.XFE_E.DP.n10 XFRONT.XFE_E.DP.n6 18.4942
R5278 XFRONT.XFE_E.DP.n11 XFRONT.XFE_E.DP.n5 18.4942
R5279 XFRONT.XFE_E.DP.n4 XFRONT.XFE_E.DP.n2 18.4942
R5280 XFRONT.XFE_E.DP.n24 XFRONT.XFE_E.DP.n23 14.5055
R5281 XFRONT.XFE_E.DP.n24 XFRONT.XFE_E.DP.n20 11.7788
R5282 XFRONT.XFE_E.DP.n16 XFRONT.XFE_E.DP.n15 11.6805
R5283 XFRONT.XFE_E.DP.n10 XFRONT.XFE_E.DP.n9 11.6805
R5284 XFRONT.XFE_E.DP.n11 XFRONT.XFE_E.DP.n10 11.6805
R5285 XFRONT.XFE_E.DP.n11 XFRONT.XFE_E.DP.n2 11.6805
R5286 XFRONT.XFE_E.DP.n15 XFRONT.XFE_E.DP.n2 11.6805
R5287 XFRONT.XFE_E.DP.n19 XFRONT.XFE_E.DP.n0 10.8396
R5288 XFRONT.XFE_E.DP.n19 XFRONT.XFE_E.DP.n18 9.0005
R5289 XFRONT.XFE_E.DP.n8 XFRONT.XFE_E.DP.n6 7.17687
R5290 XFRONT.XFE_E.DP.n18 XFRONT.XFE_E.DP.n17 7.05405
R5291 XFRONT.XFE_E.DP.n22 XFRONT.XFE_E.DP.t0 5.73764
R5292 XFRONT.XFE_E.DP.n20 XFRONT.XFE_E.DP.t1 5.70855
R5293 XFRONT.XFE_E.DP.n20 XFRONT.XFE_E.DP.t2 5.66118
R5294 XFRONT.XFE_E.DP.n23 XFRONT.XFE_E.DP.t3 5.54817
R5295 XFRONT.XFE_E.DP.n22 XFRONT.XFE_E.DP.n21 5.32067
R5296 XFRONT.XFE_E.DP XFRONT.XFE_E.DP.n19 4.79398
R5297 XFRONT.XFE_E.DP.n17 XFRONT.XFE_E.DP.n16 4.4296
R5298 XFRONT.XFE_E.DP.n9 XFRONT.XFE_E.DP.n8 4.42851
R5299 XFRONT.XFE_E.DP XFRONT.XFE_E.DP.n24 1.76137
R5300 XFRONT.XFE_E.DP.n21 XFRONT.XFE_E.DP.t5 0.228
R5301 XFRONT.XFE_E.DP.n21 XFRONT.XFE_E.DP.t4 0.228
R5302 XFRONT.XFE_E.DP.n23 XFRONT.XFE_E.DP.n22 0.189974
R5303 XFRONT.XFE_E.DP.n4 XFRONT.XFE_E.DP.n1 0.1205
R5304 XFRONT.XFE_E.DP.n5 XFRONT.XFE_E.DP.n4 0.1205
R5305 XFRONT.XFE_E.DP.n6 XFRONT.XFE_E.DP.n5 0.1205
R5306 XFRONT.XFE_E.DP.n14 XFRONT.XFE_E.DP.n13 0.1205
R5307 XFRONT.XFE_E.DP.n13 XFRONT.XFE_E.DP.n12 0.1205
R5308 XFRONT.XFE_E.DP.n12 XFRONT.XFE_E.DP.n3 0.1205
R5309 XFRONT.XFE_E.DP.n7 XFRONT.XFE_E.DP.n3 0.1205
R5310 XFRONT.XFE_E.DP.n18 XFRONT.XFE_E.DP.n1 0.1085
R5311 XFRONT.XFE_E.DP.n14 XFRONT.XFE_E.DP.n0 0.1085
R5312 XFRONT.XFE_E.DN.t6 XFRONT.XFE_E.DN.n8 127.788
R5313 XFRONT.XFE_E.DN.t13 XFRONT.XFE_E.DN.n1 127.776
R5314 XFRONT.XFE_E.DN.t11 XFRONT.XFE_E.DN.n15 127.668
R5315 XFRONT.XFE_E.DN.t12 XFRONT.XFE_E.DN.n1 127.668
R5316 XFRONT.XFE_E.DN.n8 XFRONT.XFE_E.DN.t7 127.668
R5317 XFRONT.XFE_E.DN.t8 XFRONT.XFE_E.DN.n4 127.668
R5318 XFRONT.XFE_E.DN.n13 XFRONT.XFE_E.DN.t9 127.668
R5319 XFRONT.XFE_E.DN.n14 XFRONT.XFE_E.DN.t10 127.668
R5320 XFRONT.XFE_E.DN.n9 XFRONT.XFE_E.DN.t6 113.632
R5321 XFRONT.XFE_E.DN.n18 XFRONT.XFE_E.DN.t13 113.629
R5322 XFRONT.XFE_E.DN.n16 XFRONT.XFE_E.DN.t11 109.174
R5323 XFRONT.XFE_E.DN.n17 XFRONT.XFE_E.DN.t12 109.174
R5324 XFRONT.XFE_E.DN.n10 XFRONT.XFE_E.DN.t7 109.174
R5325 XFRONT.XFE_E.DN.n11 XFRONT.XFE_E.DN.t8 109.174
R5326 XFRONT.XFE_E.DN.t9 XFRONT.XFE_E.DN.n12 109.174
R5327 XFRONT.XFE_E.DN.t10 XFRONT.XFE_E.DN.n3 109.174
R5328 XFRONT.XFE_E.DN.n16 XFRONT.XFE_E.DN.n2 18.4942
R5329 XFRONT.XFE_E.DN.n11 XFRONT.XFE_E.DN.n7 18.4942
R5330 XFRONT.XFE_E.DN.n12 XFRONT.XFE_E.DN.n6 18.4942
R5331 XFRONT.XFE_E.DN.n5 XFRONT.XFE_E.DN.n3 18.4942
R5332 XFRONT.XFE_E.DN.n24 XFRONT.XFE_E.DN.n23 14.1606
R5333 XFRONT.XFE_E.DN.n17 XFRONT.XFE_E.DN.n16 11.6805
R5334 XFRONT.XFE_E.DN.n11 XFRONT.XFE_E.DN.n10 11.6805
R5335 XFRONT.XFE_E.DN.n12 XFRONT.XFE_E.DN.n11 11.6805
R5336 XFRONT.XFE_E.DN.n12 XFRONT.XFE_E.DN.n3 11.6805
R5337 XFRONT.XFE_E.DN.n16 XFRONT.XFE_E.DN.n3 11.6805
R5338 XFRONT.XFE_E.DN.n20 XFRONT.XFE_E.DN.n1 10.8201
R5339 XFRONT.XFE_E.DN XFRONT.XFE_E.DN.n0 10.5657
R5340 XFRONT.XFE_E.DN.n20 XFRONT.XFE_E.DN.n19 9.02007
R5341 XFRONT.XFE_E.DN.n24 XFRONT.XFE_E.DN.n20 7.2005
R5342 XFRONT.XFE_E.DN.n9 XFRONT.XFE_E.DN.n7 7.17687
R5343 XFRONT.XFE_E.DN.n19 XFRONT.XFE_E.DN.n18 7.05405
R5344 XFRONT.XFE_E.DN.n0 XFRONT.XFE_E.DN.t1 5.7796
R5345 XFRONT.XFE_E.DN.n22 XFRONT.XFE_E.DN.t4 5.73764
R5346 XFRONT.XFE_E.DN.n0 XFRONT.XFE_E.DN.t0 5.59012
R5347 XFRONT.XFE_E.DN.n23 XFRONT.XFE_E.DN.t3 5.54817
R5348 XFRONT.XFE_E.DN.n22 XFRONT.XFE_E.DN.n21 5.32067
R5349 XFRONT.XFE_E.DN.n18 XFRONT.XFE_E.DN.n17 4.4296
R5350 XFRONT.XFE_E.DN.n10 XFRONT.XFE_E.DN.n9 4.42851
R5351 XFRONT.XFE_E.DN XFRONT.XFE_E.DN.n24 0.93963
R5352 XFRONT.XFE_E.DN.n21 XFRONT.XFE_E.DN.t2 0.228
R5353 XFRONT.XFE_E.DN.n21 XFRONT.XFE_E.DN.t5 0.228
R5354 XFRONT.XFE_E.DN.n23 XFRONT.XFE_E.DN.n22 0.189974
R5355 XFRONT.XFE_E.DN.n5 XFRONT.XFE_E.DN.n2 0.1205
R5356 XFRONT.XFE_E.DN.n6 XFRONT.XFE_E.DN.n5 0.1205
R5357 XFRONT.XFE_E.DN.n7 XFRONT.XFE_E.DN.n6 0.1205
R5358 XFRONT.XFE_E.DN.n15 XFRONT.XFE_E.DN.n14 0.1205
R5359 XFRONT.XFE_E.DN.n14 XFRONT.XFE_E.DN.n13 0.1205
R5360 XFRONT.XFE_E.DN.n13 XFRONT.XFE_E.DN.n4 0.1205
R5361 XFRONT.XFE_E.DN.n8 XFRONT.XFE_E.DN.n4 0.1205
R5362 XFRONT.XFE_E.DN.n19 XFRONT.XFE_E.DN.n2 0.1085
R5363 XFRONT.XFE_E.DN.n15 XFRONT.XFE_E.DN.n1 0.1085
R5364 XFRONT.XFE_O.NIN.n13 XFRONT.XFE_O.NIN.n12 19.957
R5365 XFRONT.XFE_O.NIN.n13 XFRONT.XFE_O.NIN.n9 12.3657
R5366 XFRONT.XFE_O.NIN.n21 XFRONT.XFE_O.NIN.n20 11.9353
R5367 XFRONT.XFE_O.NIN.n15 XFRONT.XFE_O.NIN.t23 5.7796
R5368 XFRONT.XFE_O.NIN.n19 XFRONT.XFE_O.NIN.t16 5.7796
R5369 XFRONT.XFE_O.NIN.n11 XFRONT.XFE_O.NIN.t15 5.73764
R5370 XFRONT.XFE_O.NIN.n12 XFRONT.XFE_O.NIN.t12 5.6429
R5371 XFRONT.XFE_O.NIN.n2 XFRONT.XFE_O.NIN.n0 5.57485
R5372 XFRONT.XFE_O.NIN.n6 XFRONT.XFE_O.NIN.n4 5.57485
R5373 XFRONT.XFE_O.NIN.n15 XFRONT.XFE_O.NIN.n14 5.38537
R5374 XFRONT.XFE_O.NIN.n2 XFRONT.XFE_O.NIN.n1 5.38537
R5375 XFRONT.XFE_O.NIN.n9 XFRONT.XFE_O.NIN.n3 5.38537
R5376 XFRONT.XFE_O.NIN.n8 XFRONT.XFE_O.NIN.n7 5.38537
R5377 XFRONT.XFE_O.NIN.n6 XFRONT.XFE_O.NIN.n5 5.38537
R5378 XFRONT.XFE_O.NIN.n17 XFRONT.XFE_O.NIN.n16 5.38537
R5379 XFRONT.XFE_O.NIN.n19 XFRONT.XFE_O.NIN.n18 5.38537
R5380 XFRONT.XFE_O.NIN.n11 XFRONT.XFE_O.NIN.n10 5.32067
R5381 XFRONT.XFE_O.NIN.n21 XFRONT.XFE_O.NIN.n13 1.95702
R5382 XFRONT.XFE_O.NIN.n10 XFRONT.XFE_O.NIN.t13 0.228
R5383 XFRONT.XFE_O.NIN.n10 XFRONT.XFE_O.NIN.t14 0.228
R5384 XFRONT.XFE_O.NIN.n14 XFRONT.XFE_O.NIN.t21 0.20525
R5385 XFRONT.XFE_O.NIN.n14 XFRONT.XFE_O.NIN.t22 0.20525
R5386 XFRONT.XFE_O.NIN.n0 XFRONT.XFE_O.NIN.t7 0.20525
R5387 XFRONT.XFE_O.NIN.n0 XFRONT.XFE_O.NIN.t6 0.20525
R5388 XFRONT.XFE_O.NIN.n1 XFRONT.XFE_O.NIN.t3 0.20525
R5389 XFRONT.XFE_O.NIN.n1 XFRONT.XFE_O.NIN.t8 0.20525
R5390 XFRONT.XFE_O.NIN.n3 XFRONT.XFE_O.NIN.t5 0.20525
R5391 XFRONT.XFE_O.NIN.n3 XFRONT.XFE_O.NIN.t4 0.20525
R5392 XFRONT.XFE_O.NIN.n7 XFRONT.XFE_O.NIN.t1 0.20525
R5393 XFRONT.XFE_O.NIN.n7 XFRONT.XFE_O.NIN.t0 0.20525
R5394 XFRONT.XFE_O.NIN.n5 XFRONT.XFE_O.NIN.t9 0.20525
R5395 XFRONT.XFE_O.NIN.n5 XFRONT.XFE_O.NIN.t2 0.20525
R5396 XFRONT.XFE_O.NIN.n4 XFRONT.XFE_O.NIN.t11 0.20525
R5397 XFRONT.XFE_O.NIN.n4 XFRONT.XFE_O.NIN.t10 0.20525
R5398 XFRONT.XFE_O.NIN.n16 XFRONT.XFE_O.NIN.t19 0.20525
R5399 XFRONT.XFE_O.NIN.n16 XFRONT.XFE_O.NIN.t20 0.20525
R5400 XFRONT.XFE_O.NIN.n18 XFRONT.XFE_O.NIN.t17 0.20525
R5401 XFRONT.XFE_O.NIN.n18 XFRONT.XFE_O.NIN.t18 0.20525
R5402 XFRONT.XFE_O.NIN.n17 XFRONT.XFE_O.NIN.n15 0.189974
R5403 XFRONT.XFE_O.NIN.n8 XFRONT.XFE_O.NIN.n6 0.189974
R5404 XFRONT.XFE_O.NIN.n9 XFRONT.XFE_O.NIN.n8 0.189974
R5405 XFRONT.XFE_O.NIN.n9 XFRONT.XFE_O.NIN.n2 0.189974
R5406 XFRONT.XFE_O.NIN.n20 XFRONT.XFE_O.NIN.n19 0.0952368
R5407 XFRONT.XFE_O.NIN.n20 XFRONT.XFE_O.NIN.n17 0.0952368
R5408 XFRONT.XFE_O.NIN.n12 XFRONT.XFE_O.NIN.n11 0.0952368
R5409 XFRONT.XFE_O.NIN XFRONT.XFE_O.NIN.n21 0.0396304
R5410 XFRONT.XFE_O.NIP.n10 XFRONT.XFE_O.NIP.n9 20.2309
R5411 XFRONT.XFE_O.NIP.n10 XFRONT.XFE_O.NIP.n6 14.1657
R5412 XFRONT.XFE_O.NIP.n21 XFRONT.XFE_O.NIP.n20 10.957
R5413 XFRONT.XFE_O.NIP.n1 XFRONT.XFE_O.NIP.t20 5.7796
R5414 XFRONT.XFE_O.NIP.n5 XFRONT.XFE_O.NIP.t13 5.7796
R5415 XFRONT.XFE_O.NIP.n8 XFRONT.XFE_O.NIP.t12 5.73764
R5416 XFRONT.XFE_O.NIP.n9 XFRONT.XFE_O.NIP.t9 5.6429
R5417 XFRONT.XFE_O.NIP.n13 XFRONT.XFE_O.NIP.n11 5.57485
R5418 XFRONT.XFE_O.NIP.n17 XFRONT.XFE_O.NIP.n15 5.57485
R5419 XFRONT.XFE_O.NIP.n13 XFRONT.XFE_O.NIP.n12 5.38537
R5420 XFRONT.XFE_O.NIP.n20 XFRONT.XFE_O.NIP.n14 5.38537
R5421 XFRONT.XFE_O.NIP.n19 XFRONT.XFE_O.NIP.n18 5.38537
R5422 XFRONT.XFE_O.NIP.n17 XFRONT.XFE_O.NIP.n16 5.38537
R5423 XFRONT.XFE_O.NIP.n1 XFRONT.XFE_O.NIP.n0 5.38537
R5424 XFRONT.XFE_O.NIP.n3 XFRONT.XFE_O.NIP.n2 5.38537
R5425 XFRONT.XFE_O.NIP.n5 XFRONT.XFE_O.NIP.n4 5.38537
R5426 XFRONT.XFE_O.NIP.n8 XFRONT.XFE_O.NIP.n7 5.32067
R5427 XFRONT.XFE_O.NIP.n21 XFRONT.XFE_O.NIP.n10 1.05702
R5428 XFRONT.XFE_O.NIP.n7 XFRONT.XFE_O.NIP.t10 0.228
R5429 XFRONT.XFE_O.NIP.n7 XFRONT.XFE_O.NIP.t11 0.228
R5430 XFRONT.XFE_O.NIP.n11 XFRONT.XFE_O.NIP.t1 0.20525
R5431 XFRONT.XFE_O.NIP.n11 XFRONT.XFE_O.NIP.t0 0.20525
R5432 XFRONT.XFE_O.NIP.n12 XFRONT.XFE_O.NIP.t6 0.20525
R5433 XFRONT.XFE_O.NIP.n12 XFRONT.XFE_O.NIP.t2 0.20525
R5434 XFRONT.XFE_O.NIP.n14 XFRONT.XFE_O.NIP.t8 0.20525
R5435 XFRONT.XFE_O.NIP.n14 XFRONT.XFE_O.NIP.t7 0.20525
R5436 XFRONT.XFE_O.NIP.n18 XFRONT.XFE_O.NIP.t4 0.20525
R5437 XFRONT.XFE_O.NIP.n18 XFRONT.XFE_O.NIP.t3 0.20525
R5438 XFRONT.XFE_O.NIP.n16 XFRONT.XFE_O.NIP.t21 0.20525
R5439 XFRONT.XFE_O.NIP.n16 XFRONT.XFE_O.NIP.t5 0.20525
R5440 XFRONT.XFE_O.NIP.n15 XFRONT.XFE_O.NIP.t23 0.20525
R5441 XFRONT.XFE_O.NIP.n15 XFRONT.XFE_O.NIP.t22 0.20525
R5442 XFRONT.XFE_O.NIP.n0 XFRONT.XFE_O.NIP.t18 0.20525
R5443 XFRONT.XFE_O.NIP.n0 XFRONT.XFE_O.NIP.t19 0.20525
R5444 XFRONT.XFE_O.NIP.n2 XFRONT.XFE_O.NIP.t16 0.20525
R5445 XFRONT.XFE_O.NIP.n2 XFRONT.XFE_O.NIP.t17 0.20525
R5446 XFRONT.XFE_O.NIP.n4 XFRONT.XFE_O.NIP.t14 0.20525
R5447 XFRONT.XFE_O.NIP.n4 XFRONT.XFE_O.NIP.t15 0.20525
R5448 XFRONT.XFE_O.NIP.n3 XFRONT.XFE_O.NIP.n1 0.189974
R5449 XFRONT.XFE_O.NIP.n19 XFRONT.XFE_O.NIP.n17 0.189974
R5450 XFRONT.XFE_O.NIP.n20 XFRONT.XFE_O.NIP.n19 0.189974
R5451 XFRONT.XFE_O.NIP.n20 XFRONT.XFE_O.NIP.n13 0.189974
R5452 XFRONT.XFE_O.NIP.n6 XFRONT.XFE_O.NIP.n5 0.0952368
R5453 XFRONT.XFE_O.NIP.n6 XFRONT.XFE_O.NIP.n3 0.0952368
R5454 XFRONT.XFE_O.NIP.n9 XFRONT.XFE_O.NIP.n8 0.0952368
R5455 XFRONT.XFE_O.NIP XFRONT.XFE_O.NIP.n21 0.0396304
R5456 XFRONT.XFE_E.NIP.n20 XFRONT.XFE_E.NIP.n19 20.2309
R5457 XFRONT.XFE_E.NIP.n20 XFRONT.XFE_E.NIP.n16 14.1657
R5458 XFRONT.XFE_E.NIP XFRONT.XFE_E.NIP.n9 10.9962
R5459 XFRONT.XFE_E.NIP.n11 XFRONT.XFE_E.NIP.t23 5.7796
R5460 XFRONT.XFE_E.NIP.n13 XFRONT.XFE_E.NIP.t16 5.7796
R5461 XFRONT.XFE_E.NIP.n18 XFRONT.XFE_E.NIP.t6 5.73764
R5462 XFRONT.XFE_E.NIP.n19 XFRONT.XFE_E.NIP.t9 5.6429
R5463 XFRONT.XFE_E.NIP.n2 XFRONT.XFE_E.NIP.n0 5.57485
R5464 XFRONT.XFE_E.NIP.n8 XFRONT.XFE_E.NIP.n6 5.57485
R5465 XFRONT.XFE_E.NIP.n11 XFRONT.XFE_E.NIP.n10 5.38537
R5466 XFRONT.XFE_E.NIP.n2 XFRONT.XFE_E.NIP.n1 5.38537
R5467 XFRONT.XFE_E.NIP.n4 XFRONT.XFE_E.NIP.n3 5.38537
R5468 XFRONT.XFE_E.NIP.n9 XFRONT.XFE_E.NIP.n5 5.38537
R5469 XFRONT.XFE_E.NIP.n8 XFRONT.XFE_E.NIP.n7 5.38537
R5470 XFRONT.XFE_E.NIP.n15 XFRONT.XFE_E.NIP.n14 5.38537
R5471 XFRONT.XFE_E.NIP.n13 XFRONT.XFE_E.NIP.n12 5.38537
R5472 XFRONT.XFE_E.NIP.n18 XFRONT.XFE_E.NIP.n17 5.32067
R5473 XFRONT.XFE_E.NIP XFRONT.XFE_E.NIP.n20 1.01789
R5474 XFRONT.XFE_E.NIP.n17 XFRONT.XFE_E.NIP.t7 0.228
R5475 XFRONT.XFE_E.NIP.n17 XFRONT.XFE_E.NIP.t8 0.228
R5476 XFRONT.XFE_E.NIP.n10 XFRONT.XFE_E.NIP.t21 0.20525
R5477 XFRONT.XFE_E.NIP.n10 XFRONT.XFE_E.NIP.t22 0.20525
R5478 XFRONT.XFE_E.NIP.n0 XFRONT.XFE_E.NIP.t5 0.20525
R5479 XFRONT.XFE_E.NIP.n0 XFRONT.XFE_E.NIP.t4 0.20525
R5480 XFRONT.XFE_E.NIP.n1 XFRONT.XFE_E.NIP.t14 0.20525
R5481 XFRONT.XFE_E.NIP.n1 XFRONT.XFE_E.NIP.t13 0.20525
R5482 XFRONT.XFE_E.NIP.n3 XFRONT.XFE_E.NIP.t10 0.20525
R5483 XFRONT.XFE_E.NIP.n3 XFRONT.XFE_E.NIP.t15 0.20525
R5484 XFRONT.XFE_E.NIP.n5 XFRONT.XFE_E.NIP.t12 0.20525
R5485 XFRONT.XFE_E.NIP.n5 XFRONT.XFE_E.NIP.t11 0.20525
R5486 XFRONT.XFE_E.NIP.n7 XFRONT.XFE_E.NIP.t1 0.20525
R5487 XFRONT.XFE_E.NIP.n7 XFRONT.XFE_E.NIP.t0 0.20525
R5488 XFRONT.XFE_E.NIP.n6 XFRONT.XFE_E.NIP.t3 0.20525
R5489 XFRONT.XFE_E.NIP.n6 XFRONT.XFE_E.NIP.t2 0.20525
R5490 XFRONT.XFE_E.NIP.n14 XFRONT.XFE_E.NIP.t19 0.20525
R5491 XFRONT.XFE_E.NIP.n14 XFRONT.XFE_E.NIP.t20 0.20525
R5492 XFRONT.XFE_E.NIP.n12 XFRONT.XFE_E.NIP.t17 0.20525
R5493 XFRONT.XFE_E.NIP.n12 XFRONT.XFE_E.NIP.t18 0.20525
R5494 XFRONT.XFE_E.NIP.n15 XFRONT.XFE_E.NIP.n13 0.189974
R5495 XFRONT.XFE_E.NIP.n9 XFRONT.XFE_E.NIP.n8 0.189974
R5496 XFRONT.XFE_E.NIP.n9 XFRONT.XFE_E.NIP.n4 0.189974
R5497 XFRONT.XFE_E.NIP.n4 XFRONT.XFE_E.NIP.n2 0.189974
R5498 XFRONT.XFE_E.NIP.n16 XFRONT.XFE_E.NIP.n15 0.0952368
R5499 XFRONT.XFE_E.NIP.n16 XFRONT.XFE_E.NIP.n11 0.0952368
R5500 XFRONT.XFE_E.NIP.n19 XFRONT.XFE_E.NIP.n18 0.0952368
R5501 XFRONT.XFE_E.NIN.n20 XFRONT.XFE_E.NIN.n19 19.957
R5502 XFRONT.XFE_E.NIN.n20 XFRONT.XFE_E.NIN.n16 12.3657
R5503 XFRONT.XFE_E.NIN XFRONT.XFE_E.NIN.n6 11.9744
R5504 XFRONT.XFE_E.NIN.n1 XFRONT.XFE_E.NIN.t20 5.7796
R5505 XFRONT.XFE_E.NIN.n3 XFRONT.XFE_E.NIN.t13 5.7796
R5506 XFRONT.XFE_E.NIN.n18 XFRONT.XFE_E.NIN.t1 5.73764
R5507 XFRONT.XFE_E.NIN.n19 XFRONT.XFE_E.NIN.t4 5.6429
R5508 XFRONT.XFE_E.NIN.n9 XFRONT.XFE_E.NIN.n7 5.57485
R5509 XFRONT.XFE_E.NIN.n15 XFRONT.XFE_E.NIN.n13 5.57485
R5510 XFRONT.XFE_E.NIN.n9 XFRONT.XFE_E.NIN.n8 5.38537
R5511 XFRONT.XFE_E.NIN.n11 XFRONT.XFE_E.NIN.n10 5.38537
R5512 XFRONT.XFE_E.NIN.n16 XFRONT.XFE_E.NIN.n12 5.38537
R5513 XFRONT.XFE_E.NIN.n15 XFRONT.XFE_E.NIN.n14 5.38537
R5514 XFRONT.XFE_E.NIN.n1 XFRONT.XFE_E.NIN.n0 5.38537
R5515 XFRONT.XFE_E.NIN.n5 XFRONT.XFE_E.NIN.n4 5.38537
R5516 XFRONT.XFE_E.NIN.n3 XFRONT.XFE_E.NIN.n2 5.38537
R5517 XFRONT.XFE_E.NIN.n18 XFRONT.XFE_E.NIN.n17 5.32067
R5518 XFRONT.XFE_E.NIN XFRONT.XFE_E.NIN.n20 1.91789
R5519 XFRONT.XFE_E.NIN.n17 XFRONT.XFE_E.NIN.t2 0.228
R5520 XFRONT.XFE_E.NIN.n17 XFRONT.XFE_E.NIN.t3 0.228
R5521 XFRONT.XFE_E.NIN.n7 XFRONT.XFE_E.NIN.t10 0.20525
R5522 XFRONT.XFE_E.NIN.n7 XFRONT.XFE_E.NIN.t0 0.20525
R5523 XFRONT.XFE_E.NIN.n8 XFRONT.XFE_E.NIN.t12 0.20525
R5524 XFRONT.XFE_E.NIN.n8 XFRONT.XFE_E.NIN.t11 0.20525
R5525 XFRONT.XFE_E.NIN.n10 XFRONT.XFE_E.NIN.t8 0.20525
R5526 XFRONT.XFE_E.NIN.n10 XFRONT.XFE_E.NIN.t7 0.20525
R5527 XFRONT.XFE_E.NIN.n12 XFRONT.XFE_E.NIN.t21 0.20525
R5528 XFRONT.XFE_E.NIN.n12 XFRONT.XFE_E.NIN.t9 0.20525
R5529 XFRONT.XFE_E.NIN.n14 XFRONT.XFE_E.NIN.t23 0.20525
R5530 XFRONT.XFE_E.NIN.n14 XFRONT.XFE_E.NIN.t22 0.20525
R5531 XFRONT.XFE_E.NIN.n13 XFRONT.XFE_E.NIN.t6 0.20525
R5532 XFRONT.XFE_E.NIN.n13 XFRONT.XFE_E.NIN.t5 0.20525
R5533 XFRONT.XFE_E.NIN.n0 XFRONT.XFE_E.NIN.t18 0.20525
R5534 XFRONT.XFE_E.NIN.n0 XFRONT.XFE_E.NIN.t19 0.20525
R5535 XFRONT.XFE_E.NIN.n4 XFRONT.XFE_E.NIN.t16 0.20525
R5536 XFRONT.XFE_E.NIN.n4 XFRONT.XFE_E.NIN.t17 0.20525
R5537 XFRONT.XFE_E.NIN.n2 XFRONT.XFE_E.NIN.t14 0.20525
R5538 XFRONT.XFE_E.NIN.n2 XFRONT.XFE_E.NIN.t15 0.20525
R5539 XFRONT.XFE_E.NIN.n5 XFRONT.XFE_E.NIN.n3 0.189974
R5540 XFRONT.XFE_E.NIN.n16 XFRONT.XFE_E.NIN.n15 0.189974
R5541 XFRONT.XFE_E.NIN.n16 XFRONT.XFE_E.NIN.n11 0.189974
R5542 XFRONT.XFE_E.NIN.n11 XFRONT.XFE_E.NIN.n9 0.189974
R5543 XFRONT.XFE_E.NIN.n6 XFRONT.XFE_E.NIN.n5 0.0952368
R5544 XFRONT.XFE_E.NIN.n6 XFRONT.XFE_E.NIN.n1 0.0952368
R5545 XFRONT.XFE_E.NIN.n19 XFRONT.XFE_E.NIN.n18 0.0952368
R5546 XFRONT.XFE_O.HB.n28 XFRONT.XFE_O.HB.t21 142.571
R5547 XFRONT.XFE_O.HB.n5 XFRONT.XFE_O.HB.t17 113.632
R5548 XFRONT.XFE_O.HB.n0 XFRONT.XFE_O.HB.t24 113.632
R5549 XFRONT.XFE_O.HB.n30 XFRONT.XFE_O.HB.t25 113.632
R5550 XFRONT.XFE_O.HB.n7 XFRONT.XFE_O.HB.t19 109.174
R5551 XFRONT.XFE_O.HB.n8 XFRONT.XFE_O.HB.t20 109.174
R5552 XFRONT.XFE_O.HB.n6 XFRONT.XFE_O.HB.t18 109.174
R5553 XFRONT.XFE_O.HB.n1 XFRONT.XFE_O.HB.t23 109.174
R5554 XFRONT.XFE_O.HB.n2 XFRONT.XFE_O.HB.t22 109.174
R5555 XFRONT.XFE_O.HB.n33 XFRONT.XFE_O.HB.t28 109.174
R5556 XFRONT.XFE_O.HB.n32 XFRONT.XFE_O.HB.t27 109.174
R5557 XFRONT.XFE_O.HB.n31 XFRONT.XFE_O.HB.t26 109.174
R5558 XFRONT.XFE_O.HB.n9 XFRONT.XFE_O.HB.n8 18.5179
R5559 XFRONT.XFE_O.HB.n7 XFRONT.XFE_O.HB.n4 18.4942
R5560 XFRONT.XFE_O.HB.n3 XFRONT.XFE_O.HB.n2 18.4942
R5561 XFRONT.XFE_O.HB.n34 XFRONT.XFE_O.HB.n33 18.4942
R5562 XFRONT.XFE_O.HB.n32 XFRONT.XFE_O.HB.n29 18.4942
R5563 XFRONT.XFE_O.HB.n27 XFRONT.XFE_O.HB.n26 17.4527
R5564 XFRONT.XFE_O.HB.n10 XFRONT.XFE_O.HB.n3 16.4663
R5565 XFRONT.XFE_O.HB.n35 XFRONT.XFE_O.HB.n34 15.8194
R5566 XFRONT.XFE_O.HB.n23 XFRONT.XFE_O.HB.t13 15.1863
R5567 XFRONT.XFE_O.HB.n10 XFRONT.XFE_O.HB.n9 14.6157
R5568 XFRONT.XFE_O.HB.n28 XFRONT.XFE_O.HB.n27 13.344
R5569 XFRONT.XFE_O.HB.n22 XFRONT.XFE_O.HB.n21 12.757
R5570 XFRONT.XFE_O.HB.n7 XFRONT.XFE_O.HB.n6 11.6805
R5571 XFRONT.XFE_O.HB.n8 XFRONT.XFE_O.HB.n7 11.6805
R5572 XFRONT.XFE_O.HB.n2 XFRONT.XFE_O.HB.n1 11.6805
R5573 XFRONT.XFE_O.HB.n33 XFRONT.XFE_O.HB.n32 11.6805
R5574 XFRONT.XFE_O.HB.n32 XFRONT.XFE_O.HB.n31 11.6805
R5575 XFRONT.XFE_O.HB.n18 XFRONT.XFE_O.HB.n17 9.43093
R5576 XFRONT.XFE_O.HB.n5 XFRONT.XFE_O.HB.n4 7.17687
R5577 XFRONT.XFE_O.HB.n3 XFRONT.XFE_O.HB.n0 7.17687
R5578 XFRONT.XFE_O.HB.n30 XFRONT.XFE_O.HB.n29 7.17687
R5579 XFRONT.XFE_O.HB.n12 XFRONT.XFE_O.HB.t7 5.7796
R5580 XFRONT.XFE_O.HB.n16 XFRONT.XFE_O.HB.t0 5.7796
R5581 XFRONT.XFE_O.HB.n20 XFRONT.XFE_O.HB.t11 5.73764
R5582 XFRONT.XFE_O.HB.n25 XFRONT.XFE_O.HB.t8 5.73764
R5583 XFRONT.XFE_O.HB.n26 XFRONT.XFE_O.HB.t14 5.71396
R5584 XFRONT.XFE_O.HB.n21 XFRONT.XFE_O.HB.t10 5.6429
R5585 XFRONT.XFE_O.HB.n12 XFRONT.XFE_O.HB.n11 5.38537
R5586 XFRONT.XFE_O.HB.n14 XFRONT.XFE_O.HB.n13 5.38537
R5587 XFRONT.XFE_O.HB.n16 XFRONT.XFE_O.HB.n15 5.38537
R5588 XFRONT.XFE_O.HB.n20 XFRONT.XFE_O.HB.n19 5.32067
R5589 XFRONT.XFE_O.HB.n25 XFRONT.XFE_O.HB.n24 5.32067
R5590 XFRONT.XFE_O.HB.n6 XFRONT.XFE_O.HB.n5 4.42851
R5591 XFRONT.XFE_O.HB.n1 XFRONT.XFE_O.HB.n0 4.42851
R5592 XFRONT.XFE_O.HB.n31 XFRONT.XFE_O.HB.n30 4.42851
R5593 XFRONT.XFE_O.HB.n18 XFRONT.XFE_O.HB.n10 3.48311
R5594 XFRONT.XFE_O.HB.n27 XFRONT.XFE_O.HB.n23 2.34833
R5595 XFRONT.XFE_O.HB.n35 XFRONT.XFE_O.HB.n28 1.17441
R5596 XFRONT.XFE_O.HB.n22 XFRONT.XFE_O.HB.n18 1.17441
R5597 XFRONT.XFE_O.HB.n23 XFRONT.XFE_O.HB.n22 0.587457
R5598 XFRONT.XFE_O.HB.n19 XFRONT.XFE_O.HB.t9 0.228
R5599 XFRONT.XFE_O.HB.n19 XFRONT.XFE_O.HB.t12 0.228
R5600 XFRONT.XFE_O.HB.n24 XFRONT.XFE_O.HB.t16 0.228
R5601 XFRONT.XFE_O.HB.n24 XFRONT.XFE_O.HB.t15 0.228
R5602 XFRONT.XFE_O.HB.n11 XFRONT.XFE_O.HB.t5 0.20525
R5603 XFRONT.XFE_O.HB.n11 XFRONT.XFE_O.HB.t6 0.20525
R5604 XFRONT.XFE_O.HB.n13 XFRONT.XFE_O.HB.t3 0.20525
R5605 XFRONT.XFE_O.HB.n13 XFRONT.XFE_O.HB.t4 0.20525
R5606 XFRONT.XFE_O.HB.n15 XFRONT.XFE_O.HB.t1 0.20525
R5607 XFRONT.XFE_O.HB.n15 XFRONT.XFE_O.HB.t2 0.20525
R5608 XFRONT.XFE_O.HB.n14 XFRONT.XFE_O.HB.n12 0.189974
R5609 XFRONT.XFE_O.HB.n34 XFRONT.XFE_O.HB.n29 0.1205
R5610 XFRONT.XFE_O.HB.n17 XFRONT.XFE_O.HB.n16 0.0952368
R5611 XFRONT.XFE_O.HB.n17 XFRONT.XFE_O.HB.n14 0.0952368
R5612 XFRONT.XFE_O.HB.n21 XFRONT.XFE_O.HB.n20 0.0952368
R5613 XFRONT.XFE_O.HB.n9 XFRONT.XFE_O.HB.n4 0.0785
R5614 XFRONT.XFE_O.HB XFRONT.XFE_O.HB.n35 0.0396304
R5615 XFRONT.XFE_O.HB.n26 XFRONT.XFE_O.HB.n25 0.0241842
R5616 XFRONT.XFE_O.H.n6 XFRONT.XFE_O.H.t17 142.148
R5617 XFRONT.XFE_O.H.n1 XFRONT.XFE_O.H.t25 113.632
R5618 XFRONT.XFE_O.H.n30 XFRONT.XFE_O.H.t18 113.632
R5619 XFRONT.XFE_O.H.n24 XFRONT.XFE_O.H.t28 113.632
R5620 XFRONT.XFE_O.H.n2 XFRONT.XFE_O.H.t24 109.174
R5621 XFRONT.XFE_O.H.n3 XFRONT.XFE_O.H.t23 109.174
R5622 XFRONT.XFE_O.H.n0 XFRONT.XFE_O.H.t22 109.174
R5623 XFRONT.XFE_O.H.n32 XFRONT.XFE_O.H.t20 109.174
R5624 XFRONT.XFE_O.H.n33 XFRONT.XFE_O.H.t21 109.174
R5625 XFRONT.XFE_O.H.n31 XFRONT.XFE_O.H.t19 109.174
R5626 XFRONT.XFE_O.H.n25 XFRONT.XFE_O.H.t27 109.174
R5627 XFRONT.XFE_O.H.n26 XFRONT.XFE_O.H.t26 109.174
R5628 XFRONT.XFE_O.H.n5 XFRONT.XFE_O.H.n0 18.5179
R5629 XFRONT.XFE_O.H.n34 XFRONT.XFE_O.H.n33 18.5179
R5630 XFRONT.XFE_O.H.n4 XFRONT.XFE_O.H.n3 18.4942
R5631 XFRONT.XFE_O.H.n32 XFRONT.XFE_O.H.n29 18.4942
R5632 XFRONT.XFE_O.H.n27 XFRONT.XFE_O.H.n26 18.4942
R5633 XFRONT.XFE_O.H.n10 XFRONT.XFE_O.H.n9 17.7266
R5634 XFRONT.XFE_O.H.n6 XFRONT.XFE_O.H.n5 16.7679
R5635 XFRONT.XFE_O.H.n28 XFRONT.XFE_O.H.n27 16.1533
R5636 XFRONT.XFE_O.H.n11 XFRONT.XFE_O.H.t6 15.3418
R5637 XFRONT.XFE_O.H.n35 XFRONT.XFE_O.H.n34 14.3418
R5638 XFRONT.XFE_O.H.n10 XFRONT.XFE_O.H.n6 13.657
R5639 XFRONT.XFE_O.H.n15 XFRONT.XFE_O.H.n14 13.0309
R5640 XFRONT.XFE_O.H.n3 XFRONT.XFE_O.H.n2 11.6805
R5641 XFRONT.XFE_O.H.n3 XFRONT.XFE_O.H.n0 11.6805
R5642 XFRONT.XFE_O.H.n32 XFRONT.XFE_O.H.n31 11.6805
R5643 XFRONT.XFE_O.H.n33 XFRONT.XFE_O.H.n32 11.6805
R5644 XFRONT.XFE_O.H.n26 XFRONT.XFE_O.H.n25 11.6805
R5645 XFRONT.XFE_O.H.n23 XFRONT.XFE_O.H.n22 9.70485
R5646 XFRONT.XFE_O.H.n4 XFRONT.XFE_O.H.n1 7.17687
R5647 XFRONT.XFE_O.H.n30 XFRONT.XFE_O.H.n29 7.17687
R5648 XFRONT.XFE_O.H.n27 XFRONT.XFE_O.H.n24 7.17687
R5649 XFRONT.XFE_O.H.n17 XFRONT.XFE_O.H.t16 5.7796
R5650 XFRONT.XFE_O.H.n21 XFRONT.XFE_O.H.t9 5.7796
R5651 XFRONT.XFE_O.H.n13 XFRONT.XFE_O.H.t5 5.73764
R5652 XFRONT.XFE_O.H.n8 XFRONT.XFE_O.H.t7 5.73764
R5653 XFRONT.XFE_O.H.n14 XFRONT.XFE_O.H.t2 5.6429
R5654 XFRONT.XFE_O.H.n9 XFRONT.XFE_O.H.t8 5.6429
R5655 XFRONT.XFE_O.H.n17 XFRONT.XFE_O.H.n16 5.38537
R5656 XFRONT.XFE_O.H.n19 XFRONT.XFE_O.H.n18 5.38537
R5657 XFRONT.XFE_O.H.n21 XFRONT.XFE_O.H.n20 5.38537
R5658 XFRONT.XFE_O.H.n13 XFRONT.XFE_O.H.n12 5.32067
R5659 XFRONT.XFE_O.H.n8 XFRONT.XFE_O.H.n7 5.32067
R5660 XFRONT.XFE_O.H.n2 XFRONT.XFE_O.H.n1 4.42851
R5661 XFRONT.XFE_O.H.n31 XFRONT.XFE_O.H.n30 4.42851
R5662 XFRONT.XFE_O.H.n25 XFRONT.XFE_O.H.n24 4.42851
R5663 XFRONT.XFE_O.H.n28 XFRONT.XFE_O.H.n23 2.97441
R5664 XFRONT.XFE_O.H.n11 XFRONT.XFE_O.H.n10 2.73963
R5665 XFRONT.XFE_O.H.n23 XFRONT.XFE_O.H.n15 1.17441
R5666 XFRONT.XFE_O.H.n35 XFRONT.XFE_O.H.n28 0.587457
R5667 XFRONT.XFE_O.H.n15 XFRONT.XFE_O.H.n11 0.391804
R5668 XFRONT.XFE_O.H.n12 XFRONT.XFE_O.H.t3 0.228
R5669 XFRONT.XFE_O.H.n12 XFRONT.XFE_O.H.t4 0.228
R5670 XFRONT.XFE_O.H.n7 XFRONT.XFE_O.H.t1 0.228
R5671 XFRONT.XFE_O.H.n7 XFRONT.XFE_O.H.t0 0.228
R5672 XFRONT.XFE_O.H.n16 XFRONT.XFE_O.H.t14 0.20525
R5673 XFRONT.XFE_O.H.n16 XFRONT.XFE_O.H.t15 0.20525
R5674 XFRONT.XFE_O.H.n18 XFRONT.XFE_O.H.t12 0.20525
R5675 XFRONT.XFE_O.H.n18 XFRONT.XFE_O.H.t13 0.20525
R5676 XFRONT.XFE_O.H.n20 XFRONT.XFE_O.H.t10 0.20525
R5677 XFRONT.XFE_O.H.n20 XFRONT.XFE_O.H.t11 0.20525
R5678 XFRONT.XFE_O.H.n19 XFRONT.XFE_O.H.n17 0.189974
R5679 XFRONT.XFE_O.H.n22 XFRONT.XFE_O.H.n21 0.0952368
R5680 XFRONT.XFE_O.H.n22 XFRONT.XFE_O.H.n19 0.0952368
R5681 XFRONT.XFE_O.H.n14 XFRONT.XFE_O.H.n13 0.0952368
R5682 XFRONT.XFE_O.H.n9 XFRONT.XFE_O.H.n8 0.0952368
R5683 XFRONT.XFE_O.H.n5 XFRONT.XFE_O.H.n4 0.0785
R5684 XFRONT.XFE_O.H.n34 XFRONT.XFE_O.H.n29 0.0785
R5685 XFRONT.XFE_O.H XFRONT.XFE_O.H.n35 0.0396304
R5686 XFRONT.XFE_E.H.n12 XFRONT.XFE_E.H.t21 142.148
R5687 XFRONT.XFE_E.H.n1 XFRONT.XFE_E.H.t20 113.632
R5688 XFRONT.XFE_E.H.n30 XFRONT.XFE_E.H.t22 113.632
R5689 XFRONT.XFE_E.H.n7 XFRONT.XFE_E.H.t25 113.632
R5690 XFRONT.XFE_E.H.n2 XFRONT.XFE_E.H.t19 109.174
R5691 XFRONT.XFE_E.H.n3 XFRONT.XFE_E.H.t18 109.174
R5692 XFRONT.XFE_E.H.n0 XFRONT.XFE_E.H.t17 109.174
R5693 XFRONT.XFE_E.H.n32 XFRONT.XFE_E.H.t24 109.174
R5694 XFRONT.XFE_E.H.n31 XFRONT.XFE_E.H.t23 109.174
R5695 XFRONT.XFE_E.H.n9 XFRONT.XFE_E.H.t27 109.174
R5696 XFRONT.XFE_E.H.n10 XFRONT.XFE_E.H.t28 109.174
R5697 XFRONT.XFE_E.H.n8 XFRONT.XFE_E.H.t26 109.174
R5698 XFRONT.XFE_E.H.n5 XFRONT.XFE_E.H.n0 18.5179
R5699 XFRONT.XFE_E.H.n11 XFRONT.XFE_E.H.n10 18.5179
R5700 XFRONT.XFE_E.H.n4 XFRONT.XFE_E.H.n3 18.4942
R5701 XFRONT.XFE_E.H.n33 XFRONT.XFE_E.H.n32 18.4942
R5702 XFRONT.XFE_E.H.n9 XFRONT.XFE_E.H.n6 18.4942
R5703 XFRONT.XFE_E.H.n16 XFRONT.XFE_E.H.n15 17.7266
R5704 XFRONT.XFE_E.H.n12 XFRONT.XFE_E.H.n11 16.7679
R5705 XFRONT.XFE_E.H.n34 XFRONT.XFE_E.H.n33 16.1533
R5706 XFRONT.XFE_E.H.n17 XFRONT.XFE_E.H.t0 15.3418
R5707 XFRONT.XFE_E.H XFRONT.XFE_E.H.n5 14.3809
R5708 XFRONT.XFE_E.H.n16 XFRONT.XFE_E.H.n12 13.657
R5709 XFRONT.XFE_E.H.n21 XFRONT.XFE_E.H.n20 13.0309
R5710 XFRONT.XFE_E.H.n3 XFRONT.XFE_E.H.n2 11.6805
R5711 XFRONT.XFE_E.H.n3 XFRONT.XFE_E.H.n0 11.6805
R5712 XFRONT.XFE_E.H.n32 XFRONT.XFE_E.H.n31 11.6805
R5713 XFRONT.XFE_E.H.n9 XFRONT.XFE_E.H.n8 11.6805
R5714 XFRONT.XFE_E.H.n10 XFRONT.XFE_E.H.n9 11.6805
R5715 XFRONT.XFE_E.H.n29 XFRONT.XFE_E.H.n28 9.70485
R5716 XFRONT.XFE_E.H.n4 XFRONT.XFE_E.H.n1 7.17687
R5717 XFRONT.XFE_E.H.n33 XFRONT.XFE_E.H.n30 7.17687
R5718 XFRONT.XFE_E.H.n7 XFRONT.XFE_E.H.n6 7.17687
R5719 XFRONT.XFE_E.H.n23 XFRONT.XFE_E.H.t11 5.7796
R5720 XFRONT.XFE_E.H.n25 XFRONT.XFE_E.H.t4 5.7796
R5721 XFRONT.XFE_E.H.n19 XFRONT.XFE_E.H.t1 5.73764
R5722 XFRONT.XFE_E.H.n14 XFRONT.XFE_E.H.t15 5.73764
R5723 XFRONT.XFE_E.H.n20 XFRONT.XFE_E.H.t16 5.6429
R5724 XFRONT.XFE_E.H.n15 XFRONT.XFE_E.H.t12 5.6429
R5725 XFRONT.XFE_E.H.n23 XFRONT.XFE_E.H.n22 5.38537
R5726 XFRONT.XFE_E.H.n27 XFRONT.XFE_E.H.n26 5.38537
R5727 XFRONT.XFE_E.H.n25 XFRONT.XFE_E.H.n24 5.38537
R5728 XFRONT.XFE_E.H.n19 XFRONT.XFE_E.H.n18 5.32067
R5729 XFRONT.XFE_E.H.n14 XFRONT.XFE_E.H.n13 5.32067
R5730 XFRONT.XFE_E.H.n2 XFRONT.XFE_E.H.n1 4.42851
R5731 XFRONT.XFE_E.H.n31 XFRONT.XFE_E.H.n30 4.42851
R5732 XFRONT.XFE_E.H.n8 XFRONT.XFE_E.H.n7 4.42851
R5733 XFRONT.XFE_E.H.n34 XFRONT.XFE_E.H.n29 2.97441
R5734 XFRONT.XFE_E.H.n17 XFRONT.XFE_E.H.n16 2.73963
R5735 XFRONT.XFE_E.H.n29 XFRONT.XFE_E.H.n21 1.17441
R5736 XFRONT.XFE_E.H XFRONT.XFE_E.H.n34 0.548326
R5737 XFRONT.XFE_E.H.n21 XFRONT.XFE_E.H.n17 0.391804
R5738 XFRONT.XFE_E.H.n18 XFRONT.XFE_E.H.t3 0.228
R5739 XFRONT.XFE_E.H.n18 XFRONT.XFE_E.H.t2 0.228
R5740 XFRONT.XFE_E.H.n13 XFRONT.XFE_E.H.t14 0.228
R5741 XFRONT.XFE_E.H.n13 XFRONT.XFE_E.H.t13 0.228
R5742 XFRONT.XFE_E.H.n22 XFRONT.XFE_E.H.t9 0.20525
R5743 XFRONT.XFE_E.H.n22 XFRONT.XFE_E.H.t10 0.20525
R5744 XFRONT.XFE_E.H.n26 XFRONT.XFE_E.H.t7 0.20525
R5745 XFRONT.XFE_E.H.n26 XFRONT.XFE_E.H.t8 0.20525
R5746 XFRONT.XFE_E.H.n24 XFRONT.XFE_E.H.t5 0.20525
R5747 XFRONT.XFE_E.H.n24 XFRONT.XFE_E.H.t6 0.20525
R5748 XFRONT.XFE_E.H.n27 XFRONT.XFE_E.H.n25 0.189974
R5749 XFRONT.XFE_E.H.n28 XFRONT.XFE_E.H.n27 0.0952368
R5750 XFRONT.XFE_E.H.n28 XFRONT.XFE_E.H.n23 0.0952368
R5751 XFRONT.XFE_E.H.n20 XFRONT.XFE_E.H.n19 0.0952368
R5752 XFRONT.XFE_E.H.n15 XFRONT.XFE_E.H.n14 0.0952368
R5753 XFRONT.XFE_E.H.n5 XFRONT.XFE_E.H.n4 0.0785
R5754 XFRONT.XFE_E.H.n11 XFRONT.XFE_E.H.n6 0.0785
R5755 XFRONT.XFE_E.HB.n34 XFRONT.XFE_E.HB.t17 142.571
R5756 XFRONT.XFE_E.HB.n1 XFRONT.XFE_E.HB.t25 113.632
R5757 XFRONT.XFE_E.HB.n11 XFRONT.XFE_E.HB.t21 113.632
R5758 XFRONT.XFE_E.HB.n6 XFRONT.XFE_E.HB.t26 113.632
R5759 XFRONT.XFE_E.HB.n2 XFRONT.XFE_E.HB.t24 109.174
R5760 XFRONT.XFE_E.HB.n3 XFRONT.XFE_E.HB.t23 109.174
R5761 XFRONT.XFE_E.HB.n4 XFRONT.XFE_E.HB.t22 109.174
R5762 XFRONT.XFE_E.HB.n12 XFRONT.XFE_E.HB.t20 109.174
R5763 XFRONT.XFE_E.HB.n13 XFRONT.XFE_E.HB.t19 109.174
R5764 XFRONT.XFE_E.HB.n10 XFRONT.XFE_E.HB.t18 109.174
R5765 XFRONT.XFE_E.HB.n8 XFRONT.XFE_E.HB.t28 109.174
R5766 XFRONT.XFE_E.HB.n7 XFRONT.XFE_E.HB.t27 109.174
R5767 XFRONT.XFE_E.HB.n15 XFRONT.XFE_E.HB.n10 18.5179
R5768 XFRONT.XFE_E.HB.n3 XFRONT.XFE_E.HB.n0 18.4942
R5769 XFRONT.XFE_E.HB.n5 XFRONT.XFE_E.HB.n4 18.4942
R5770 XFRONT.XFE_E.HB.n14 XFRONT.XFE_E.HB.n13 18.4942
R5771 XFRONT.XFE_E.HB.n9 XFRONT.XFE_E.HB.n8 18.4942
R5772 XFRONT.XFE_E.HB.n33 XFRONT.XFE_E.HB.n32 17.4527
R5773 XFRONT.XFE_E.HB.n16 XFRONT.XFE_E.HB.n9 16.4663
R5774 XFRONT.XFE_E.HB XFRONT.XFE_E.HB.n5 15.8585
R5775 XFRONT.XFE_E.HB.n29 XFRONT.XFE_E.HB.t16 15.1863
R5776 XFRONT.XFE_E.HB.n16 XFRONT.XFE_E.HB.n15 14.6157
R5777 XFRONT.XFE_E.HB.n34 XFRONT.XFE_E.HB.n33 13.344
R5778 XFRONT.XFE_E.HB.n28 XFRONT.XFE_E.HB.n27 12.757
R5779 XFRONT.XFE_E.HB.n3 XFRONT.XFE_E.HB.n2 11.6805
R5780 XFRONT.XFE_E.HB.n4 XFRONT.XFE_E.HB.n3 11.6805
R5781 XFRONT.XFE_E.HB.n13 XFRONT.XFE_E.HB.n12 11.6805
R5782 XFRONT.XFE_E.HB.n13 XFRONT.XFE_E.HB.n10 11.6805
R5783 XFRONT.XFE_E.HB.n8 XFRONT.XFE_E.HB.n7 11.6805
R5784 XFRONT.XFE_E.HB.n24 XFRONT.XFE_E.HB.n23 9.43093
R5785 XFRONT.XFE_E.HB.n1 XFRONT.XFE_E.HB.n0 7.17687
R5786 XFRONT.XFE_E.HB.n14 XFRONT.XFE_E.HB.n11 7.17687
R5787 XFRONT.XFE_E.HB.n9 XFRONT.XFE_E.HB.n6 7.17687
R5788 XFRONT.XFE_E.HB.n18 XFRONT.XFE_E.HB.t10 5.7796
R5789 XFRONT.XFE_E.HB.n20 XFRONT.XFE_E.HB.t3 5.7796
R5790 XFRONT.XFE_E.HB.n26 XFRONT.XFE_E.HB.t12 5.73764
R5791 XFRONT.XFE_E.HB.n31 XFRONT.XFE_E.HB.t2 5.73764
R5792 XFRONT.XFE_E.HB.n32 XFRONT.XFE_E.HB.t11 5.71396
R5793 XFRONT.XFE_E.HB.n27 XFRONT.XFE_E.HB.t15 5.6429
R5794 XFRONT.XFE_E.HB.n18 XFRONT.XFE_E.HB.n17 5.38537
R5795 XFRONT.XFE_E.HB.n22 XFRONT.XFE_E.HB.n21 5.38537
R5796 XFRONT.XFE_E.HB.n20 XFRONT.XFE_E.HB.n19 5.38537
R5797 XFRONT.XFE_E.HB.n26 XFRONT.XFE_E.HB.n25 5.32067
R5798 XFRONT.XFE_E.HB.n31 XFRONT.XFE_E.HB.n30 5.32067
R5799 XFRONT.XFE_E.HB.n2 XFRONT.XFE_E.HB.n1 4.42851
R5800 XFRONT.XFE_E.HB.n12 XFRONT.XFE_E.HB.n11 4.42851
R5801 XFRONT.XFE_E.HB.n7 XFRONT.XFE_E.HB.n6 4.42851
R5802 XFRONT.XFE_E.HB.n24 XFRONT.XFE_E.HB.n16 3.48311
R5803 XFRONT.XFE_E.HB.n33 XFRONT.XFE_E.HB.n29 2.34833
R5804 XFRONT.XFE_E.HB.n28 XFRONT.XFE_E.HB.n24 1.17441
R5805 XFRONT.XFE_E.HB XFRONT.XFE_E.HB.n34 1.13528
R5806 XFRONT.XFE_E.HB.n29 XFRONT.XFE_E.HB.n28 0.587457
R5807 XFRONT.XFE_E.HB.n25 XFRONT.XFE_E.HB.t13 0.228
R5808 XFRONT.XFE_E.HB.n25 XFRONT.XFE_E.HB.t14 0.228
R5809 XFRONT.XFE_E.HB.n30 XFRONT.XFE_E.HB.t1 0.228
R5810 XFRONT.XFE_E.HB.n30 XFRONT.XFE_E.HB.t0 0.228
R5811 XFRONT.XFE_E.HB.n17 XFRONT.XFE_E.HB.t8 0.20525
R5812 XFRONT.XFE_E.HB.n17 XFRONT.XFE_E.HB.t9 0.20525
R5813 XFRONT.XFE_E.HB.n21 XFRONT.XFE_E.HB.t6 0.20525
R5814 XFRONT.XFE_E.HB.n21 XFRONT.XFE_E.HB.t7 0.20525
R5815 XFRONT.XFE_E.HB.n19 XFRONT.XFE_E.HB.t4 0.20525
R5816 XFRONT.XFE_E.HB.n19 XFRONT.XFE_E.HB.t5 0.20525
R5817 XFRONT.XFE_E.HB.n22 XFRONT.XFE_E.HB.n20 0.189974
R5818 XFRONT.XFE_E.HB.n5 XFRONT.XFE_E.HB.n0 0.1205
R5819 XFRONT.XFE_E.HB.n23 XFRONT.XFE_E.HB.n22 0.0952368
R5820 XFRONT.XFE_E.HB.n23 XFRONT.XFE_E.HB.n18 0.0952368
R5821 XFRONT.XFE_E.HB.n27 XFRONT.XFE_E.HB.n26 0.0952368
R5822 XFRONT.XFE_E.HB.n15 XFRONT.XFE_E.HB.n14 0.0785
R5823 XFRONT.XFE_E.HB.n32 XFRONT.XFE_E.HB.n31 0.0241842
R5824 XFRONT.XFE_O.XP.t43 XFRONT.XFE_O.XP.n25 127.788
R5825 XFRONT.XFE_O.XP.t32 XFRONT.XFE_O.XP.n10 127.788
R5826 XFRONT.XFE_O.XP.t34 XFRONT.XFE_O.XP.n7 127.668
R5827 XFRONT.XFE_O.XP.n25 XFRONT.XFE_O.XP.t42 127.668
R5828 XFRONT.XFE_O.XP.n24 XFRONT.XFE_O.XP.t41 127.668
R5829 XFRONT.XFE_O.XP.n23 XFRONT.XFE_O.XP.t40 127.668
R5830 XFRONT.XFE_O.XP.n22 XFRONT.XFE_O.XP.t39 127.668
R5831 XFRONT.XFE_O.XP.n21 XFRONT.XFE_O.XP.t38 127.668
R5832 XFRONT.XFE_O.XP.n20 XFRONT.XFE_O.XP.t37 127.668
R5833 XFRONT.XFE_O.XP.t36 XFRONT.XFE_O.XP.n8 127.668
R5834 XFRONT.XFE_O.XP.n35 XFRONT.XFE_O.XP.t35 127.668
R5835 XFRONT.XFE_O.XP.n10 XFRONT.XFE_O.XP.t33 127.668
R5836 XFRONT.XFE_O.XP.n26 XFRONT.XFE_O.XP.t43 113.632
R5837 XFRONT.XFE_O.XP.n11 XFRONT.XFE_O.XP.t32 113.632
R5838 XFRONT.XFE_O.XP.n1 XFRONT.XFE_O.XP.t53 113.632
R5839 XFRONT.XFE_O.XP.n38 XFRONT.XFE_O.XP.t54 113.632
R5840 XFRONT.XFE_O.XP.n62 XFRONT.XFE_O.XP.t45 113.632
R5841 XFRONT.XFE_O.XP.n65 XFRONT.XFE_O.XP.t49 113.632
R5842 XFRONT.XFE_O.XP.n38 XFRONT.XFE_O.XP.t55 113.603
R5843 XFRONT.XFE_O.XP.n62 XFRONT.XFE_O.XP.t44 113.603
R5844 XFRONT.XFE_O.XP.n13 XFRONT.XFE_O.XP.t34 109.174
R5845 XFRONT.XFE_O.XP.t42 XFRONT.XFE_O.XP.n19 109.174
R5846 XFRONT.XFE_O.XP.n28 XFRONT.XFE_O.XP.t41 109.174
R5847 XFRONT.XFE_O.XP.n29 XFRONT.XFE_O.XP.t40 109.174
R5848 XFRONT.XFE_O.XP.n30 XFRONT.XFE_O.XP.t39 109.174
R5849 XFRONT.XFE_O.XP.n31 XFRONT.XFE_O.XP.t38 109.174
R5850 XFRONT.XFE_O.XP.n32 XFRONT.XFE_O.XP.t37 109.174
R5851 XFRONT.XFE_O.XP.n33 XFRONT.XFE_O.XP.t36 109.174
R5852 XFRONT.XFE_O.XP.t35 XFRONT.XFE_O.XP.n34 109.174
R5853 XFRONT.XFE_O.XP.t33 XFRONT.XFE_O.XP.n9 109.174
R5854 XFRONT.XFE_O.XP.n2 XFRONT.XFE_O.XP.t52 109.174
R5855 XFRONT.XFE_O.XP.n3 XFRONT.XFE_O.XP.t51 109.174
R5856 XFRONT.XFE_O.XP.n4 XFRONT.XFE_O.XP.t50 109.174
R5857 XFRONT.XFE_O.XP.n66 XFRONT.XFE_O.XP.t48 109.174
R5858 XFRONT.XFE_O.XP.n67 XFRONT.XFE_O.XP.t47 109.174
R5859 XFRONT.XFE_O.XP.n64 XFRONT.XFE_O.XP.t46 109.174
R5860 XFRONT.XFE_O.XP.n39 XFRONT.XFE_O.XP.n38 26.8696
R5861 XFRONT.XFE_O.XP.n63 XFRONT.XFE_O.XP.n62 22.8718
R5862 XFRONT.XFE_O.XP.n37 XFRONT.XFE_O.XP.n5 20.2802
R5863 XFRONT.XFE_O.XP.n69 XFRONT.XFE_O.XP.n64 18.5179
R5864 XFRONT.XFE_O.XP.n13 XFRONT.XFE_O.XP.n12 18.4942
R5865 XFRONT.XFE_O.XP.n28 XFRONT.XFE_O.XP.n27 18.4942
R5866 XFRONT.XFE_O.XP.n29 XFRONT.XFE_O.XP.n18 18.4942
R5867 XFRONT.XFE_O.XP.n30 XFRONT.XFE_O.XP.n17 18.4942
R5868 XFRONT.XFE_O.XP.n31 XFRONT.XFE_O.XP.n16 18.4942
R5869 XFRONT.XFE_O.XP.n32 XFRONT.XFE_O.XP.n15 18.4942
R5870 XFRONT.XFE_O.XP.n33 XFRONT.XFE_O.XP.n14 18.4942
R5871 XFRONT.XFE_O.XP.n34 XFRONT.XFE_O.XP.n6 18.4942
R5872 XFRONT.XFE_O.XP.n3 XFRONT.XFE_O.XP.n0 18.4942
R5873 XFRONT.XFE_O.XP.n5 XFRONT.XFE_O.XP.n4 18.4942
R5874 XFRONT.XFE_O.XP.n68 XFRONT.XFE_O.XP.n67 18.4942
R5875 XFRONT.XFE_O.XP.n49 XFRONT.XFE_O.XP.n48 16.6309
R5876 XFRONT.XFE_O.XP.n70 XFRONT.XFE_O.XP.n69 14.8896
R5877 XFRONT.XFE_O.XP.n80 XFRONT.XFE_O.XP.n79 14.2831
R5878 XFRONT.XFE_O.XP.n47 XFRONT.XFE_O.XP.n46 14.2831
R5879 XFRONT.XFE_O.XP.n61 XFRONT.XFE_O.XP.n60 11.7396
R5880 XFRONT.XFE_O.XP.n29 XFRONT.XFE_O.XP.n28 11.6805
R5881 XFRONT.XFE_O.XP.n28 XFRONT.XFE_O.XP.n19 11.6805
R5882 XFRONT.XFE_O.XP.n30 XFRONT.XFE_O.XP.n29 11.6805
R5883 XFRONT.XFE_O.XP.n31 XFRONT.XFE_O.XP.n30 11.6805
R5884 XFRONT.XFE_O.XP.n32 XFRONT.XFE_O.XP.n31 11.6805
R5885 XFRONT.XFE_O.XP.n33 XFRONT.XFE_O.XP.n32 11.6805
R5886 XFRONT.XFE_O.XP.n34 XFRONT.XFE_O.XP.n33 11.6805
R5887 XFRONT.XFE_O.XP.n34 XFRONT.XFE_O.XP.n13 11.6805
R5888 XFRONT.XFE_O.XP.n13 XFRONT.XFE_O.XP.n9 11.6805
R5889 XFRONT.XFE_O.XP.n3 XFRONT.XFE_O.XP.n2 11.6805
R5890 XFRONT.XFE_O.XP.n4 XFRONT.XFE_O.XP.n3 11.6805
R5891 XFRONT.XFE_O.XP.n67 XFRONT.XFE_O.XP.n66 11.6805
R5892 XFRONT.XFE_O.XP.n67 XFRONT.XFE_O.XP.n64 11.6805
R5893 XFRONT.XFE_O.XP.n36 XFRONT.XFE_O.XP.n6 10.8396
R5894 XFRONT.XFE_O.XP.n36 XFRONT.XFE_O.XP.n35 9.0005
R5895 XFRONT.XFE_O.XP.n27 XFRONT.XFE_O.XP.n26 7.17687
R5896 XFRONT.XFE_O.XP.n12 XFRONT.XFE_O.XP.n11 7.17687
R5897 XFRONT.XFE_O.XP.n1 XFRONT.XFE_O.XP.n0 7.17687
R5898 XFRONT.XFE_O.XP.n68 XFRONT.XFE_O.XP.n65 7.17687
R5899 XFRONT.XFE_O.XP.n37 XFRONT.XFE_O.XP.n36 6.94615
R5900 XFRONT.XFE_O.XP.n51 XFRONT.XFE_O.XP.t0 5.7796
R5901 XFRONT.XFE_O.XP.n57 XFRONT.XFE_O.XP.t31 5.7796
R5902 XFRONT.XFE_O.XP.n72 XFRONT.XFE_O.XP.t25 5.73764
R5903 XFRONT.XFE_O.XP.n41 XFRONT.XFE_O.XP.t15 5.73764
R5904 XFRONT.XFE_O.XP.n45 XFRONT.XFE_O.XP.t11 5.73764
R5905 XFRONT.XFE_O.XP.n48 XFRONT.XFE_O.XP.t28 5.66659
R5906 XFRONT.XFE_O.XP.n48 XFRONT.XFE_O.XP.t27 5.61922
R5907 XFRONT.XFE_O.XP.n79 XFRONT.XFE_O.XP.t16 5.57185
R5908 XFRONT.XFE_O.XP.n51 XFRONT.XFE_O.XP.n50 5.38537
R5909 XFRONT.XFE_O.XP.n53 XFRONT.XFE_O.XP.n52 5.38537
R5910 XFRONT.XFE_O.XP.n55 XFRONT.XFE_O.XP.n54 5.38537
R5911 XFRONT.XFE_O.XP.n59 XFRONT.XFE_O.XP.n58 5.38537
R5912 XFRONT.XFE_O.XP.n57 XFRONT.XFE_O.XP.n56 5.38537
R5913 XFRONT.XFE_O.XP.n41 XFRONT.XFE_O.XP.n40 5.32067
R5914 XFRONT.XFE_O.XP.n43 XFRONT.XFE_O.XP.n42 5.32067
R5915 XFRONT.XFE_O.XP.n45 XFRONT.XFE_O.XP.n44 5.32067
R5916 XFRONT.XFE_O.XP.n72 XFRONT.XFE_O.XP.n71 5.32067
R5917 XFRONT.XFE_O.XP.n74 XFRONT.XFE_O.XP.n73 5.32067
R5918 XFRONT.XFE_O.XP.n76 XFRONT.XFE_O.XP.n75 5.32067
R5919 XFRONT.XFE_O.XP.n78 XFRONT.XFE_O.XP.n77 5.32067
R5920 XFRONT.XFE_O.XP.n26 XFRONT.XFE_O.XP.n19 4.42851
R5921 XFRONT.XFE_O.XP.n11 XFRONT.XFE_O.XP.n9 4.42851
R5922 XFRONT.XFE_O.XP.n2 XFRONT.XFE_O.XP.n1 4.42851
R5923 XFRONT.XFE_O.XP.n66 XFRONT.XFE_O.XP.n65 4.42851
R5924 XFRONT.XFE_O.XP.n39 XFRONT.XFE_O.XP.n37 3.71789
R5925 XFRONT.XFE_O.XP.n61 XFRONT.XFE_O.XP.n49 3.13093
R5926 XFRONT.XFE_O.XP.n49 XFRONT.XFE_O.XP.n47 1.76137
R5927 XFRONT.XFE_O.XP.n47 XFRONT.XFE_O.XP.n39 1.72224
R5928 XFRONT.XFE_O.XP.n80 XFRONT.XFE_O.XP.n70 1.33093
R5929 XFRONT.XFE_O.XP.n63 XFRONT.XFE_O.XP.n61 1.01789
R5930 XFRONT.XFE_O.XP.n70 XFRONT.XFE_O.XP.n63 0.391804
R5931 XFRONT.XFE_O.XP.n40 XFRONT.XFE_O.XP.t26 0.228
R5932 XFRONT.XFE_O.XP.n40 XFRONT.XFE_O.XP.t10 0.228
R5933 XFRONT.XFE_O.XP.n42 XFRONT.XFE_O.XP.t14 0.228
R5934 XFRONT.XFE_O.XP.n42 XFRONT.XFE_O.XP.t9 0.228
R5935 XFRONT.XFE_O.XP.n44 XFRONT.XFE_O.XP.t12 0.228
R5936 XFRONT.XFE_O.XP.n44 XFRONT.XFE_O.XP.t13 0.228
R5937 XFRONT.XFE_O.XP.n71 XFRONT.XFE_O.XP.t23 0.228
R5938 XFRONT.XFE_O.XP.n71 XFRONT.XFE_O.XP.t24 0.228
R5939 XFRONT.XFE_O.XP.n73 XFRONT.XFE_O.XP.t21 0.228
R5940 XFRONT.XFE_O.XP.n73 XFRONT.XFE_O.XP.t22 0.228
R5941 XFRONT.XFE_O.XP.n75 XFRONT.XFE_O.XP.t19 0.228
R5942 XFRONT.XFE_O.XP.n75 XFRONT.XFE_O.XP.t20 0.228
R5943 XFRONT.XFE_O.XP.n77 XFRONT.XFE_O.XP.t17 0.228
R5944 XFRONT.XFE_O.XP.n77 XFRONT.XFE_O.XP.t18 0.228
R5945 XFRONT.XFE_O.XP.n50 XFRONT.XFE_O.XP.t2 0.20525
R5946 XFRONT.XFE_O.XP.n50 XFRONT.XFE_O.XP.t1 0.20525
R5947 XFRONT.XFE_O.XP.n52 XFRONT.XFE_O.XP.t7 0.20525
R5948 XFRONT.XFE_O.XP.n52 XFRONT.XFE_O.XP.t6 0.20525
R5949 XFRONT.XFE_O.XP.n54 XFRONT.XFE_O.XP.t3 0.20525
R5950 XFRONT.XFE_O.XP.n54 XFRONT.XFE_O.XP.t8 0.20525
R5951 XFRONT.XFE_O.XP.n58 XFRONT.XFE_O.XP.t5 0.20525
R5952 XFRONT.XFE_O.XP.n58 XFRONT.XFE_O.XP.t4 0.20525
R5953 XFRONT.XFE_O.XP.n56 XFRONT.XFE_O.XP.t30 0.20525
R5954 XFRONT.XFE_O.XP.n56 XFRONT.XFE_O.XP.t29 0.20525
R5955 XFRONT.XFE_O.XP.n78 XFRONT.XFE_O.XP.n76 0.189974
R5956 XFRONT.XFE_O.XP.n76 XFRONT.XFE_O.XP.n74 0.189974
R5957 XFRONT.XFE_O.XP.n74 XFRONT.XFE_O.XP.n72 0.189974
R5958 XFRONT.XFE_O.XP.n43 XFRONT.XFE_O.XP.n41 0.189974
R5959 XFRONT.XFE_O.XP.n59 XFRONT.XFE_O.XP.n57 0.189974
R5960 XFRONT.XFE_O.XP.n55 XFRONT.XFE_O.XP.n53 0.189974
R5961 XFRONT.XFE_O.XP.n53 XFRONT.XFE_O.XP.n51 0.189974
R5962 XFRONT.XFE_O.XP.n79 XFRONT.XFE_O.XP.n78 0.166289
R5963 XFRONT.XFE_O.XP.n10 XFRONT.XFE_O.XP.n7 0.1205
R5964 XFRONT.XFE_O.XP.n25 XFRONT.XFE_O.XP.n24 0.1205
R5965 XFRONT.XFE_O.XP.n24 XFRONT.XFE_O.XP.n23 0.1205
R5966 XFRONT.XFE_O.XP.n23 XFRONT.XFE_O.XP.n22 0.1205
R5967 XFRONT.XFE_O.XP.n22 XFRONT.XFE_O.XP.n21 0.1205
R5968 XFRONT.XFE_O.XP.n21 XFRONT.XFE_O.XP.n20 0.1205
R5969 XFRONT.XFE_O.XP.n20 XFRONT.XFE_O.XP.n8 0.1205
R5970 XFRONT.XFE_O.XP.n27 XFRONT.XFE_O.XP.n18 0.1205
R5971 XFRONT.XFE_O.XP.n18 XFRONT.XFE_O.XP.n17 0.1205
R5972 XFRONT.XFE_O.XP.n17 XFRONT.XFE_O.XP.n16 0.1205
R5973 XFRONT.XFE_O.XP.n16 XFRONT.XFE_O.XP.n15 0.1205
R5974 XFRONT.XFE_O.XP.n15 XFRONT.XFE_O.XP.n14 0.1205
R5975 XFRONT.XFE_O.XP.n5 XFRONT.XFE_O.XP.n0 0.1205
R5976 XFRONT.XFE_O.XP.n12 XFRONT.XFE_O.XP.n6 0.1085
R5977 XFRONT.XFE_O.XP.n35 XFRONT.XFE_O.XP.n7 0.1085
R5978 XFRONT.XFE_O.XP.n35 XFRONT.XFE_O.XP.n8 0.1085
R5979 XFRONT.XFE_O.XP.n14 XFRONT.XFE_O.XP.n6 0.1085
R5980 XFRONT.XFE_O.XP.n46 XFRONT.XFE_O.XP.n45 0.0952368
R5981 XFRONT.XFE_O.XP.n46 XFRONT.XFE_O.XP.n43 0.0952368
R5982 XFRONT.XFE_O.XP.n60 XFRONT.XFE_O.XP.n59 0.0952368
R5983 XFRONT.XFE_O.XP.n60 XFRONT.XFE_O.XP.n55 0.0952368
R5984 XFRONT.XFE_O.XP.n69 XFRONT.XFE_O.XP.n68 0.0785
R5985 XFRONT.XFE_O.XP XFRONT.XFE_O.XP.n80 0.0396304
R5986 XFRONT.XFE_O.XN.t43 XFRONT.XFE_O.XN.n60 127.788
R5987 XFRONT.XFE_O.XN.t32 XFRONT.XFE_O.XN.n45 127.788
R5988 XFRONT.XFE_O.XN.t34 XFRONT.XFE_O.XN.n42 127.668
R5989 XFRONT.XFE_O.XN.n60 XFRONT.XFE_O.XN.t42 127.668
R5990 XFRONT.XFE_O.XN.n59 XFRONT.XFE_O.XN.t41 127.668
R5991 XFRONT.XFE_O.XN.n58 XFRONT.XFE_O.XN.t40 127.668
R5992 XFRONT.XFE_O.XN.n57 XFRONT.XFE_O.XN.t39 127.668
R5993 XFRONT.XFE_O.XN.n56 XFRONT.XFE_O.XN.t38 127.668
R5994 XFRONT.XFE_O.XN.n55 XFRONT.XFE_O.XN.t37 127.668
R5995 XFRONT.XFE_O.XN.t36 XFRONT.XFE_O.XN.n43 127.668
R5996 XFRONT.XFE_O.XN.n70 XFRONT.XFE_O.XN.t35 127.668
R5997 XFRONT.XFE_O.XN.n45 XFRONT.XFE_O.XN.t33 127.668
R5998 XFRONT.XFE_O.XN.n16 XFRONT.XFE_O.XN.t44 113.632
R5999 XFRONT.XFE_O.XN.n10 XFRONT.XFE_O.XN.t46 113.632
R6000 XFRONT.XFE_O.XN.n61 XFRONT.XFE_O.XN.t43 113.632
R6001 XFRONT.XFE_O.XN.n46 XFRONT.XFE_O.XN.t32 113.632
R6002 XFRONT.XFE_O.XN.n39 XFRONT.XFE_O.XN.t51 113.632
R6003 XFRONT.XFE_O.XN.n74 XFRONT.XFE_O.XN.t55 113.632
R6004 XFRONT.XFE_O.XN.n16 XFRONT.XFE_O.XN.t45 113.603
R6005 XFRONT.XFE_O.XN.n39 XFRONT.XFE_O.XN.t50 113.603
R6006 XFRONT.XFE_O.XN.n12 XFRONT.XFE_O.XN.t48 109.174
R6007 XFRONT.XFE_O.XN.n13 XFRONT.XFE_O.XN.t49 109.174
R6008 XFRONT.XFE_O.XN.n11 XFRONT.XFE_O.XN.t47 109.174
R6009 XFRONT.XFE_O.XN.n48 XFRONT.XFE_O.XN.t34 109.174
R6010 XFRONT.XFE_O.XN.t42 XFRONT.XFE_O.XN.n54 109.174
R6011 XFRONT.XFE_O.XN.n63 XFRONT.XFE_O.XN.t41 109.174
R6012 XFRONT.XFE_O.XN.n64 XFRONT.XFE_O.XN.t40 109.174
R6013 XFRONT.XFE_O.XN.n65 XFRONT.XFE_O.XN.t39 109.174
R6014 XFRONT.XFE_O.XN.n66 XFRONT.XFE_O.XN.t38 109.174
R6015 XFRONT.XFE_O.XN.n67 XFRONT.XFE_O.XN.t37 109.174
R6016 XFRONT.XFE_O.XN.n68 XFRONT.XFE_O.XN.t36 109.174
R6017 XFRONT.XFE_O.XN.t35 XFRONT.XFE_O.XN.n69 109.174
R6018 XFRONT.XFE_O.XN.t33 XFRONT.XFE_O.XN.n44 109.174
R6019 XFRONT.XFE_O.XN.n75 XFRONT.XFE_O.XN.t54 109.174
R6020 XFRONT.XFE_O.XN.n76 XFRONT.XFE_O.XN.t53 109.174
R6021 XFRONT.XFE_O.XN.n73 XFRONT.XFE_O.XN.t52 109.174
R6022 XFRONT.XFE_O.XN.n40 XFRONT.XFE_O.XN.n39 26.5957
R6023 XFRONT.XFE_O.XN.n17 XFRONT.XFE_O.XN.n16 23.1457
R6024 XFRONT.XFE_O.XN.n79 XFRONT.XFE_O.XN.n78 19.3114
R6025 XFRONT.XFE_O.XN.n14 XFRONT.XFE_O.XN.n13 18.5179
R6026 XFRONT.XFE_O.XN.n78 XFRONT.XFE_O.XN.n73 18.5179
R6027 XFRONT.XFE_O.XN.n12 XFRONT.XFE_O.XN.n9 18.4942
R6028 XFRONT.XFE_O.XN.n48 XFRONT.XFE_O.XN.n47 18.4942
R6029 XFRONT.XFE_O.XN.n63 XFRONT.XFE_O.XN.n62 18.4942
R6030 XFRONT.XFE_O.XN.n64 XFRONT.XFE_O.XN.n53 18.4942
R6031 XFRONT.XFE_O.XN.n65 XFRONT.XFE_O.XN.n52 18.4942
R6032 XFRONT.XFE_O.XN.n66 XFRONT.XFE_O.XN.n51 18.4942
R6033 XFRONT.XFE_O.XN.n67 XFRONT.XFE_O.XN.n50 18.4942
R6034 XFRONT.XFE_O.XN.n68 XFRONT.XFE_O.XN.n49 18.4942
R6035 XFRONT.XFE_O.XN.n69 XFRONT.XFE_O.XN.n41 18.4942
R6036 XFRONT.XFE_O.XN.n77 XFRONT.XFE_O.XN.n76 18.4942
R6037 XFRONT.XFE_O.XN.n31 XFRONT.XFE_O.XN.n30 16.357
R6038 XFRONT.XFE_O.XN.n15 XFRONT.XFE_O.XN.n8 15.2222
R6039 XFRONT.XFE_O.XN.n15 XFRONT.XFE_O.XN.n14 14.6157
R6040 XFRONT.XFE_O.XN.n38 XFRONT.XFE_O.XN.n37 12.757
R6041 XFRONT.XFE_O.XN.n29 XFRONT.XFE_O.XN.n28 12.0135
R6042 XFRONT.XFE_O.XN.n12 XFRONT.XFE_O.XN.n11 11.6805
R6043 XFRONT.XFE_O.XN.n13 XFRONT.XFE_O.XN.n12 11.6805
R6044 XFRONT.XFE_O.XN.n64 XFRONT.XFE_O.XN.n63 11.6805
R6045 XFRONT.XFE_O.XN.n63 XFRONT.XFE_O.XN.n54 11.6805
R6046 XFRONT.XFE_O.XN.n65 XFRONT.XFE_O.XN.n64 11.6805
R6047 XFRONT.XFE_O.XN.n66 XFRONT.XFE_O.XN.n65 11.6805
R6048 XFRONT.XFE_O.XN.n67 XFRONT.XFE_O.XN.n66 11.6805
R6049 XFRONT.XFE_O.XN.n68 XFRONT.XFE_O.XN.n67 11.6805
R6050 XFRONT.XFE_O.XN.n69 XFRONT.XFE_O.XN.n68 11.6805
R6051 XFRONT.XFE_O.XN.n69 XFRONT.XFE_O.XN.n48 11.6805
R6052 XFRONT.XFE_O.XN.n48 XFRONT.XFE_O.XN.n44 11.6805
R6053 XFRONT.XFE_O.XN.n76 XFRONT.XFE_O.XN.n75 11.6805
R6054 XFRONT.XFE_O.XN.n76 XFRONT.XFE_O.XN.n73 11.6805
R6055 XFRONT.XFE_O.XN.n71 XFRONT.XFE_O.XN.n41 10.8396
R6056 XFRONT.XFE_O.XN.n71 XFRONT.XFE_O.XN.n70 9.0005
R6057 XFRONT.XFE_O.XN.n72 XFRONT.XFE_O.XN.n71 7.22007
R6058 XFRONT.XFE_O.XN.n10 XFRONT.XFE_O.XN.n9 7.17687
R6059 XFRONT.XFE_O.XN.n62 XFRONT.XFE_O.XN.n61 7.17687
R6060 XFRONT.XFE_O.XN.n47 XFRONT.XFE_O.XN.n46 7.17687
R6061 XFRONT.XFE_O.XN.n77 XFRONT.XFE_O.XN.n74 7.17687
R6062 XFRONT.XFE_O.XN.n19 XFRONT.XFE_O.XN.t29 5.7796
R6063 XFRONT.XFE_O.XN.n25 XFRONT.XFE_O.XN.t18 5.7796
R6064 XFRONT.XFE_O.XN.n1 XFRONT.XFE_O.XN.t0 5.73764
R6065 XFRONT.XFE_O.XN.n30 XFRONT.XFE_O.XN.t31 5.73764
R6066 XFRONT.XFE_O.XN.n8 XFRONT.XFE_O.XN.t9 5.6429
R6067 XFRONT.XFE_O.XN.n30 XFRONT.XFE_O.XN.t30 5.54817
R6068 XFRONT.XFE_O.XN.n37 XFRONT.XFE_O.XN.n32 5.51014
R6069 XFRONT.XFE_O.XN.n36 XFRONT.XFE_O.XN.n34 5.51014
R6070 XFRONT.XFE_O.XN.n19 XFRONT.XFE_O.XN.n18 5.38537
R6071 XFRONT.XFE_O.XN.n21 XFRONT.XFE_O.XN.n20 5.38537
R6072 XFRONT.XFE_O.XN.n23 XFRONT.XFE_O.XN.n22 5.38537
R6073 XFRONT.XFE_O.XN.n27 XFRONT.XFE_O.XN.n26 5.38537
R6074 XFRONT.XFE_O.XN.n25 XFRONT.XFE_O.XN.n24 5.38537
R6075 XFRONT.XFE_O.XN.n7 XFRONT.XFE_O.XN.n6 5.32067
R6076 XFRONT.XFE_O.XN.n5 XFRONT.XFE_O.XN.n4 5.32067
R6077 XFRONT.XFE_O.XN.n3 XFRONT.XFE_O.XN.n2 5.32067
R6078 XFRONT.XFE_O.XN.n1 XFRONT.XFE_O.XN.n0 5.32067
R6079 XFRONT.XFE_O.XN.n37 XFRONT.XFE_O.XN.n33 5.32067
R6080 XFRONT.XFE_O.XN.n36 XFRONT.XFE_O.XN.n35 5.32067
R6081 XFRONT.XFE_O.XN.n11 XFRONT.XFE_O.XN.n10 4.42851
R6082 XFRONT.XFE_O.XN.n61 XFRONT.XFE_O.XN.n54 4.42851
R6083 XFRONT.XFE_O.XN.n46 XFRONT.XFE_O.XN.n44 4.42851
R6084 XFRONT.XFE_O.XN.n75 XFRONT.XFE_O.XN.n74 4.42851
R6085 XFRONT.XFE_O.XN.n72 XFRONT.XFE_O.XN.n40 2.93528
R6086 XFRONT.XFE_O.XN.n31 XFRONT.XFE_O.XN.n29 2.93528
R6087 XFRONT.XFE_O.XN.n40 XFRONT.XFE_O.XN.n38 1.72224
R6088 XFRONT.XFE_O.XN.n38 XFRONT.XFE_O.XN.n31 1.64398
R6089 XFRONT.XFE_O.XN.n29 XFRONT.XFE_O.XN.n17 1.33093
R6090 XFRONT.XFE_O.XN.n79 XFRONT.XFE_O.XN.n72 0.783109
R6091 XFRONT.XFE_O.XN.n17 XFRONT.XFE_O.XN.n15 0.391804
R6092 XFRONT.XFE_O.XN.n6 XFRONT.XFE_O.XN.t7 0.228
R6093 XFRONT.XFE_O.XN.n6 XFRONT.XFE_O.XN.t8 0.228
R6094 XFRONT.XFE_O.XN.n4 XFRONT.XFE_O.XN.t5 0.228
R6095 XFRONT.XFE_O.XN.n4 XFRONT.XFE_O.XN.t6 0.228
R6096 XFRONT.XFE_O.XN.n2 XFRONT.XFE_O.XN.t3 0.228
R6097 XFRONT.XFE_O.XN.n2 XFRONT.XFE_O.XN.t4 0.228
R6098 XFRONT.XFE_O.XN.n0 XFRONT.XFE_O.XN.t1 0.228
R6099 XFRONT.XFE_O.XN.n0 XFRONT.XFE_O.XN.t2 0.228
R6100 XFRONT.XFE_O.XN.n32 XFRONT.XFE_O.XN.t16 0.228
R6101 XFRONT.XFE_O.XN.n32 XFRONT.XFE_O.XN.t17 0.228
R6102 XFRONT.XFE_O.XN.n33 XFRONT.XFE_O.XN.t14 0.228
R6103 XFRONT.XFE_O.XN.n33 XFRONT.XFE_O.XN.t15 0.228
R6104 XFRONT.XFE_O.XN.n35 XFRONT.XFE_O.XN.t12 0.228
R6105 XFRONT.XFE_O.XN.n35 XFRONT.XFE_O.XN.t13 0.228
R6106 XFRONT.XFE_O.XN.n34 XFRONT.XFE_O.XN.t10 0.228
R6107 XFRONT.XFE_O.XN.n34 XFRONT.XFE_O.XN.t11 0.228
R6108 XFRONT.XFE_O.XN.n18 XFRONT.XFE_O.XN.t27 0.20525
R6109 XFRONT.XFE_O.XN.n18 XFRONT.XFE_O.XN.t28 0.20525
R6110 XFRONT.XFE_O.XN.n20 XFRONT.XFE_O.XN.t25 0.20525
R6111 XFRONT.XFE_O.XN.n20 XFRONT.XFE_O.XN.t26 0.20525
R6112 XFRONT.XFE_O.XN.n22 XFRONT.XFE_O.XN.t23 0.20525
R6113 XFRONT.XFE_O.XN.n22 XFRONT.XFE_O.XN.t24 0.20525
R6114 XFRONT.XFE_O.XN.n26 XFRONT.XFE_O.XN.t21 0.20525
R6115 XFRONT.XFE_O.XN.n26 XFRONT.XFE_O.XN.t22 0.20525
R6116 XFRONT.XFE_O.XN.n24 XFRONT.XFE_O.XN.t19 0.20525
R6117 XFRONT.XFE_O.XN.n24 XFRONT.XFE_O.XN.t20 0.20525
R6118 XFRONT.XFE_O.XN.n27 XFRONT.XFE_O.XN.n25 0.189974
R6119 XFRONT.XFE_O.XN.n23 XFRONT.XFE_O.XN.n21 0.189974
R6120 XFRONT.XFE_O.XN.n21 XFRONT.XFE_O.XN.n19 0.189974
R6121 XFRONT.XFE_O.XN.n3 XFRONT.XFE_O.XN.n1 0.189974
R6122 XFRONT.XFE_O.XN.n5 XFRONT.XFE_O.XN.n3 0.189974
R6123 XFRONT.XFE_O.XN.n7 XFRONT.XFE_O.XN.n5 0.189974
R6124 XFRONT.XFE_O.XN.n37 XFRONT.XFE_O.XN.n36 0.189974
R6125 XFRONT.XFE_O.XN.n45 XFRONT.XFE_O.XN.n42 0.1205
R6126 XFRONT.XFE_O.XN.n60 XFRONT.XFE_O.XN.n59 0.1205
R6127 XFRONT.XFE_O.XN.n59 XFRONT.XFE_O.XN.n58 0.1205
R6128 XFRONT.XFE_O.XN.n58 XFRONT.XFE_O.XN.n57 0.1205
R6129 XFRONT.XFE_O.XN.n57 XFRONT.XFE_O.XN.n56 0.1205
R6130 XFRONT.XFE_O.XN.n56 XFRONT.XFE_O.XN.n55 0.1205
R6131 XFRONT.XFE_O.XN.n55 XFRONT.XFE_O.XN.n43 0.1205
R6132 XFRONT.XFE_O.XN.n62 XFRONT.XFE_O.XN.n53 0.1205
R6133 XFRONT.XFE_O.XN.n53 XFRONT.XFE_O.XN.n52 0.1205
R6134 XFRONT.XFE_O.XN.n52 XFRONT.XFE_O.XN.n51 0.1205
R6135 XFRONT.XFE_O.XN.n51 XFRONT.XFE_O.XN.n50 0.1205
R6136 XFRONT.XFE_O.XN.n50 XFRONT.XFE_O.XN.n49 0.1205
R6137 XFRONT.XFE_O.XN.n47 XFRONT.XFE_O.XN.n41 0.1085
R6138 XFRONT.XFE_O.XN.n70 XFRONT.XFE_O.XN.n42 0.1085
R6139 XFRONT.XFE_O.XN.n70 XFRONT.XFE_O.XN.n43 0.1085
R6140 XFRONT.XFE_O.XN.n49 XFRONT.XFE_O.XN.n41 0.1085
R6141 XFRONT.XFE_O.XN.n28 XFRONT.XFE_O.XN.n27 0.0952368
R6142 XFRONT.XFE_O.XN.n28 XFRONT.XFE_O.XN.n23 0.0952368
R6143 XFRONT.XFE_O.XN.n8 XFRONT.XFE_O.XN.n7 0.0952368
R6144 XFRONT.XFE_O.XN.n14 XFRONT.XFE_O.XN.n9 0.0785
R6145 XFRONT.XFE_O.XN.n78 XFRONT.XFE_O.XN.n77 0.0785
R6146 XFRONT.XFE_O.XN XFRONT.XFE_O.XN.n79 0.0396304
R6147 XFRONT.XFE_E.XN.t43 XFRONT.XFE_E.XN.n71 127.788
R6148 XFRONT.XFE_E.XN.t32 XFRONT.XFE_E.XN.n59 127.788
R6149 XFRONT.XFE_E.XN.t39 XFRONT.XFE_E.XN.n48 127.668
R6150 XFRONT.XFE_E.XN.n71 XFRONT.XFE_E.XN.t42 127.668
R6151 XFRONT.XFE_E.XN.t41 XFRONT.XFE_E.XN.n49 127.668
R6152 XFRONT.XFE_E.XN.n76 XFRONT.XFE_E.XN.t40 127.668
R6153 XFRONT.XFE_E.XN.n59 XFRONT.XFE_E.XN.t33 127.668
R6154 XFRONT.XFE_E.XN.n58 XFRONT.XFE_E.XN.t34 127.668
R6155 XFRONT.XFE_E.XN.n57 XFRONT.XFE_E.XN.t35 127.668
R6156 XFRONT.XFE_E.XN.n56 XFRONT.XFE_E.XN.t36 127.668
R6157 XFRONT.XFE_E.XN.n55 XFRONT.XFE_E.XN.t37 127.668
R6158 XFRONT.XFE_E.XN.n54 XFRONT.XFE_E.XN.t38 127.668
R6159 XFRONT.XFE_E.XN.n72 XFRONT.XFE_E.XN.t43 113.632
R6160 XFRONT.XFE_E.XN.n60 XFRONT.XFE_E.XN.t32 113.632
R6161 XFRONT.XFE_E.XN.n1 XFRONT.XFE_E.XN.t50 113.632
R6162 XFRONT.XFE_E.XN.n45 XFRONT.XFE_E.XN.t54 113.632
R6163 XFRONT.XFE_E.XN.n22 XFRONT.XFE_E.XN.t45 113.632
R6164 XFRONT.XFE_E.XN.n16 XFRONT.XFE_E.XN.t49 113.632
R6165 XFRONT.XFE_E.XN.n45 XFRONT.XFE_E.XN.t55 113.603
R6166 XFRONT.XFE_E.XN.n22 XFRONT.XFE_E.XN.t44 113.603
R6167 XFRONT.XFE_E.XN.n69 XFRONT.XFE_E.XN.t39 109.174
R6168 XFRONT.XFE_E.XN.t42 XFRONT.XFE_E.XN.n70 109.174
R6169 XFRONT.XFE_E.XN.n74 XFRONT.XFE_E.XN.t41 109.174
R6170 XFRONT.XFE_E.XN.t40 XFRONT.XFE_E.XN.n75 109.174
R6171 XFRONT.XFE_E.XN.n61 XFRONT.XFE_E.XN.t33 109.174
R6172 XFRONT.XFE_E.XN.n62 XFRONT.XFE_E.XN.t34 109.174
R6173 XFRONT.XFE_E.XN.n63 XFRONT.XFE_E.XN.t35 109.174
R6174 XFRONT.XFE_E.XN.n64 XFRONT.XFE_E.XN.t36 109.174
R6175 XFRONT.XFE_E.XN.n65 XFRONT.XFE_E.XN.t37 109.174
R6176 XFRONT.XFE_E.XN.t38 XFRONT.XFE_E.XN.n50 109.174
R6177 XFRONT.XFE_E.XN.n3 XFRONT.XFE_E.XN.t52 109.174
R6178 XFRONT.XFE_E.XN.n4 XFRONT.XFE_E.XN.t53 109.174
R6179 XFRONT.XFE_E.XN.n2 XFRONT.XFE_E.XN.t51 109.174
R6180 XFRONT.XFE_E.XN.n17 XFRONT.XFE_E.XN.t48 109.174
R6181 XFRONT.XFE_E.XN.n18 XFRONT.XFE_E.XN.t47 109.174
R6182 XFRONT.XFE_E.XN.n15 XFRONT.XFE_E.XN.t46 109.174
R6183 XFRONT.XFE_E.XN.n46 XFRONT.XFE_E.XN.n45 26.5957
R6184 XFRONT.XFE_E.XN.n23 XFRONT.XFE_E.XN.n22 23.1457
R6185 XFRONT.XFE_E.XN XFRONT.XFE_E.XN.n5 19.3505
R6186 XFRONT.XFE_E.XN.n5 XFRONT.XFE_E.XN.n4 18.5179
R6187 XFRONT.XFE_E.XN.n20 XFRONT.XFE_E.XN.n15 18.5179
R6188 XFRONT.XFE_E.XN.n69 XFRONT.XFE_E.XN.n68 18.4942
R6189 XFRONT.XFE_E.XN.n74 XFRONT.XFE_E.XN.n73 18.4942
R6190 XFRONT.XFE_E.XN.n75 XFRONT.XFE_E.XN.n47 18.4942
R6191 XFRONT.XFE_E.XN.n62 XFRONT.XFE_E.XN.n53 18.4942
R6192 XFRONT.XFE_E.XN.n63 XFRONT.XFE_E.XN.n52 18.4942
R6193 XFRONT.XFE_E.XN.n64 XFRONT.XFE_E.XN.n51 18.4942
R6194 XFRONT.XFE_E.XN.n66 XFRONT.XFE_E.XN.n65 18.4942
R6195 XFRONT.XFE_E.XN.n67 XFRONT.XFE_E.XN.n50 18.4942
R6196 XFRONT.XFE_E.XN.n3 XFRONT.XFE_E.XN.n0 18.4942
R6197 XFRONT.XFE_E.XN.n19 XFRONT.XFE_E.XN.n18 18.4942
R6198 XFRONT.XFE_E.XN.n37 XFRONT.XFE_E.XN.n36 16.357
R6199 XFRONT.XFE_E.XN.n21 XFRONT.XFE_E.XN.n14 15.2222
R6200 XFRONT.XFE_E.XN.n21 XFRONT.XFE_E.XN.n20 14.6157
R6201 XFRONT.XFE_E.XN.n44 XFRONT.XFE_E.XN.n43 12.757
R6202 XFRONT.XFE_E.XN.n35 XFRONT.XFE_E.XN.n34 12.0135
R6203 XFRONT.XFE_E.XN.n75 XFRONT.XFE_E.XN.n74 11.6805
R6204 XFRONT.XFE_E.XN.n74 XFRONT.XFE_E.XN.n70 11.6805
R6205 XFRONT.XFE_E.XN.n75 XFRONT.XFE_E.XN.n69 11.6805
R6206 XFRONT.XFE_E.XN.n62 XFRONT.XFE_E.XN.n61 11.6805
R6207 XFRONT.XFE_E.XN.n63 XFRONT.XFE_E.XN.n62 11.6805
R6208 XFRONT.XFE_E.XN.n64 XFRONT.XFE_E.XN.n63 11.6805
R6209 XFRONT.XFE_E.XN.n65 XFRONT.XFE_E.XN.n64 11.6805
R6210 XFRONT.XFE_E.XN.n65 XFRONT.XFE_E.XN.n50 11.6805
R6211 XFRONT.XFE_E.XN.n69 XFRONT.XFE_E.XN.n50 11.6805
R6212 XFRONT.XFE_E.XN.n3 XFRONT.XFE_E.XN.n2 11.6805
R6213 XFRONT.XFE_E.XN.n4 XFRONT.XFE_E.XN.n3 11.6805
R6214 XFRONT.XFE_E.XN.n18 XFRONT.XFE_E.XN.n17 11.6805
R6215 XFRONT.XFE_E.XN.n18 XFRONT.XFE_E.XN.n15 11.6805
R6216 XFRONT.XFE_E.XN.n77 XFRONT.XFE_E.XN.n47 10.8396
R6217 XFRONT.XFE_E.XN.n77 XFRONT.XFE_E.XN.n76 9.0005
R6218 XFRONT.XFE_E.XN.n78 XFRONT.XFE_E.XN.n77 7.22007
R6219 XFRONT.XFE_E.XN.n73 XFRONT.XFE_E.XN.n72 7.17687
R6220 XFRONT.XFE_E.XN.n60 XFRONT.XFE_E.XN.n53 7.17687
R6221 XFRONT.XFE_E.XN.n1 XFRONT.XFE_E.XN.n0 7.17687
R6222 XFRONT.XFE_E.XN.n19 XFRONT.XFE_E.XN.n16 7.17687
R6223 XFRONT.XFE_E.XN.n25 XFRONT.XFE_E.XN.t2 5.7796
R6224 XFRONT.XFE_E.XN.n29 XFRONT.XFE_E.XN.t22 5.7796
R6225 XFRONT.XFE_E.XN.n7 XFRONT.XFE_E.XN.t16 5.73764
R6226 XFRONT.XFE_E.XN.n36 XFRONT.XFE_E.XN.t0 5.73764
R6227 XFRONT.XFE_E.XN.n14 XFRONT.XFE_E.XN.t7 5.6429
R6228 XFRONT.XFE_E.XN.n36 XFRONT.XFE_E.XN.t1 5.54817
R6229 XFRONT.XFE_E.XN.n40 XFRONT.XFE_E.XN.n38 5.51014
R6230 XFRONT.XFE_E.XN.n43 XFRONT.XFE_E.XN.n42 5.51014
R6231 XFRONT.XFE_E.XN.n25 XFRONT.XFE_E.XN.n24 5.38537
R6232 XFRONT.XFE_E.XN.n27 XFRONT.XFE_E.XN.n26 5.38537
R6233 XFRONT.XFE_E.XN.n33 XFRONT.XFE_E.XN.n32 5.38537
R6234 XFRONT.XFE_E.XN.n31 XFRONT.XFE_E.XN.n30 5.38537
R6235 XFRONT.XFE_E.XN.n29 XFRONT.XFE_E.XN.n28 5.38537
R6236 XFRONT.XFE_E.XN.n40 XFRONT.XFE_E.XN.n39 5.32067
R6237 XFRONT.XFE_E.XN.n43 XFRONT.XFE_E.XN.n41 5.32067
R6238 XFRONT.XFE_E.XN.n7 XFRONT.XFE_E.XN.n6 5.32067
R6239 XFRONT.XFE_E.XN.n9 XFRONT.XFE_E.XN.n8 5.32067
R6240 XFRONT.XFE_E.XN.n11 XFRONT.XFE_E.XN.n10 5.32067
R6241 XFRONT.XFE_E.XN.n13 XFRONT.XFE_E.XN.n12 5.32067
R6242 XFRONT.XFE_E.XN.n72 XFRONT.XFE_E.XN.n70 4.42851
R6243 XFRONT.XFE_E.XN.n61 XFRONT.XFE_E.XN.n60 4.42851
R6244 XFRONT.XFE_E.XN.n2 XFRONT.XFE_E.XN.n1 4.42851
R6245 XFRONT.XFE_E.XN.n17 XFRONT.XFE_E.XN.n16 4.42851
R6246 XFRONT.XFE_E.XN.n37 XFRONT.XFE_E.XN.n35 2.93528
R6247 XFRONT.XFE_E.XN.n78 XFRONT.XFE_E.XN.n46 2.93528
R6248 XFRONT.XFE_E.XN.n46 XFRONT.XFE_E.XN.n44 1.72224
R6249 XFRONT.XFE_E.XN.n44 XFRONT.XFE_E.XN.n37 1.64398
R6250 XFRONT.XFE_E.XN.n35 XFRONT.XFE_E.XN.n23 1.33093
R6251 XFRONT.XFE_E.XN XFRONT.XFE_E.XN.n78 0.743978
R6252 XFRONT.XFE_E.XN.n23 XFRONT.XFE_E.XN.n21 0.391804
R6253 XFRONT.XFE_E.XN.n38 XFRONT.XFE_E.XN.t3 0.228
R6254 XFRONT.XFE_E.XN.n38 XFRONT.XFE_E.XN.t5 0.228
R6255 XFRONT.XFE_E.XN.n39 XFRONT.XFE_E.XN.t19 0.228
R6256 XFRONT.XFE_E.XN.n39 XFRONT.XFE_E.XN.t4 0.228
R6257 XFRONT.XFE_E.XN.n41 XFRONT.XFE_E.XN.t17 0.228
R6258 XFRONT.XFE_E.XN.n41 XFRONT.XFE_E.XN.t6 0.228
R6259 XFRONT.XFE_E.XN.n42 XFRONT.XFE_E.XN.t20 0.228
R6260 XFRONT.XFE_E.XN.n42 XFRONT.XFE_E.XN.t18 0.228
R6261 XFRONT.XFE_E.XN.n6 XFRONT.XFE_E.XN.t14 0.228
R6262 XFRONT.XFE_E.XN.n6 XFRONT.XFE_E.XN.t15 0.228
R6263 XFRONT.XFE_E.XN.n8 XFRONT.XFE_E.XN.t12 0.228
R6264 XFRONT.XFE_E.XN.n8 XFRONT.XFE_E.XN.t13 0.228
R6265 XFRONT.XFE_E.XN.n10 XFRONT.XFE_E.XN.t10 0.228
R6266 XFRONT.XFE_E.XN.n10 XFRONT.XFE_E.XN.t11 0.228
R6267 XFRONT.XFE_E.XN.n12 XFRONT.XFE_E.XN.t8 0.228
R6268 XFRONT.XFE_E.XN.n12 XFRONT.XFE_E.XN.t9 0.228
R6269 XFRONT.XFE_E.XN.n24 XFRONT.XFE_E.XN.t27 0.20525
R6270 XFRONT.XFE_E.XN.n24 XFRONT.XFE_E.XN.t26 0.20525
R6271 XFRONT.XFE_E.XN.n26 XFRONT.XFE_E.XN.t23 0.20525
R6272 XFRONT.XFE_E.XN.n26 XFRONT.XFE_E.XN.t28 0.20525
R6273 XFRONT.XFE_E.XN.n32 XFRONT.XFE_E.XN.t25 0.20525
R6274 XFRONT.XFE_E.XN.n32 XFRONT.XFE_E.XN.t24 0.20525
R6275 XFRONT.XFE_E.XN.n30 XFRONT.XFE_E.XN.t30 0.20525
R6276 XFRONT.XFE_E.XN.n30 XFRONT.XFE_E.XN.t29 0.20525
R6277 XFRONT.XFE_E.XN.n28 XFRONT.XFE_E.XN.t21 0.20525
R6278 XFRONT.XFE_E.XN.n28 XFRONT.XFE_E.XN.t31 0.20525
R6279 XFRONT.XFE_E.XN.n13 XFRONT.XFE_E.XN.n11 0.189974
R6280 XFRONT.XFE_E.XN.n11 XFRONT.XFE_E.XN.n9 0.189974
R6281 XFRONT.XFE_E.XN.n9 XFRONT.XFE_E.XN.n7 0.189974
R6282 XFRONT.XFE_E.XN.n43 XFRONT.XFE_E.XN.n40 0.189974
R6283 XFRONT.XFE_E.XN.n31 XFRONT.XFE_E.XN.n29 0.189974
R6284 XFRONT.XFE_E.XN.n33 XFRONT.XFE_E.XN.n31 0.189974
R6285 XFRONT.XFE_E.XN.n27 XFRONT.XFE_E.XN.n25 0.189974
R6286 XFRONT.XFE_E.XN.n68 XFRONT.XFE_E.XN.n67 0.1205
R6287 XFRONT.XFE_E.XN.n67 XFRONT.XFE_E.XN.n66 0.1205
R6288 XFRONT.XFE_E.XN.n66 XFRONT.XFE_E.XN.n51 0.1205
R6289 XFRONT.XFE_E.XN.n52 XFRONT.XFE_E.XN.n51 0.1205
R6290 XFRONT.XFE_E.XN.n53 XFRONT.XFE_E.XN.n52 0.1205
R6291 XFRONT.XFE_E.XN.n54 XFRONT.XFE_E.XN.n48 0.1205
R6292 XFRONT.XFE_E.XN.n55 XFRONT.XFE_E.XN.n54 0.1205
R6293 XFRONT.XFE_E.XN.n56 XFRONT.XFE_E.XN.n55 0.1205
R6294 XFRONT.XFE_E.XN.n57 XFRONT.XFE_E.XN.n56 0.1205
R6295 XFRONT.XFE_E.XN.n58 XFRONT.XFE_E.XN.n57 0.1205
R6296 XFRONT.XFE_E.XN.n59 XFRONT.XFE_E.XN.n58 0.1205
R6297 XFRONT.XFE_E.XN.n71 XFRONT.XFE_E.XN.n49 0.1205
R6298 XFRONT.XFE_E.XN.n68 XFRONT.XFE_E.XN.n47 0.1085
R6299 XFRONT.XFE_E.XN.n76 XFRONT.XFE_E.XN.n48 0.1085
R6300 XFRONT.XFE_E.XN.n76 XFRONT.XFE_E.XN.n49 0.1085
R6301 XFRONT.XFE_E.XN.n73 XFRONT.XFE_E.XN.n47 0.1085
R6302 XFRONT.XFE_E.XN.n14 XFRONT.XFE_E.XN.n13 0.0952368
R6303 XFRONT.XFE_E.XN.n34 XFRONT.XFE_E.XN.n33 0.0952368
R6304 XFRONT.XFE_E.XN.n34 XFRONT.XFE_E.XN.n27 0.0952368
R6305 XFRONT.XFE_E.XN.n5 XFRONT.XFE_E.XN.n0 0.0785
R6306 XFRONT.XFE_E.XN.n20 XFRONT.XFE_E.XN.n19 0.0785
R6307 XFRONT.XFE_E.XP.t43 XFRONT.XFE_E.XP.n39 127.788
R6308 XFRONT.XFE_E.XP.t32 XFRONT.XFE_E.XP.n27 127.788
R6309 XFRONT.XFE_E.XP.t39 XFRONT.XFE_E.XP.n16 127.668
R6310 XFRONT.XFE_E.XP.n39 XFRONT.XFE_E.XP.t42 127.668
R6311 XFRONT.XFE_E.XP.t41 XFRONT.XFE_E.XP.n17 127.668
R6312 XFRONT.XFE_E.XP.n44 XFRONT.XFE_E.XP.t40 127.668
R6313 XFRONT.XFE_E.XP.n27 XFRONT.XFE_E.XP.t33 127.668
R6314 XFRONT.XFE_E.XP.n26 XFRONT.XFE_E.XP.t34 127.668
R6315 XFRONT.XFE_E.XP.n25 XFRONT.XFE_E.XP.t35 127.668
R6316 XFRONT.XFE_E.XP.n24 XFRONT.XFE_E.XP.t36 127.668
R6317 XFRONT.XFE_E.XP.n23 XFRONT.XFE_E.XP.t37 127.668
R6318 XFRONT.XFE_E.XP.n22 XFRONT.XFE_E.XP.t38 127.668
R6319 XFRONT.XFE_E.XP.n71 XFRONT.XFE_E.XP.t44 113.632
R6320 XFRONT.XFE_E.XP.n74 XFRONT.XFE_E.XP.t46 113.632
R6321 XFRONT.XFE_E.XP.n40 XFRONT.XFE_E.XP.t43 113.632
R6322 XFRONT.XFE_E.XP.n28 XFRONT.XFE_E.XP.t32 113.632
R6323 XFRONT.XFE_E.XP.n47 XFRONT.XFE_E.XP.t51 113.632
R6324 XFRONT.XFE_E.XP.n10 XFRONT.XFE_E.XP.t52 113.632
R6325 XFRONT.XFE_E.XP.n71 XFRONT.XFE_E.XP.t45 113.603
R6326 XFRONT.XFE_E.XP.n47 XFRONT.XFE_E.XP.t50 113.603
R6327 XFRONT.XFE_E.XP.n76 XFRONT.XFE_E.XP.t48 109.174
R6328 XFRONT.XFE_E.XP.n77 XFRONT.XFE_E.XP.t49 109.174
R6329 XFRONT.XFE_E.XP.n75 XFRONT.XFE_E.XP.t47 109.174
R6330 XFRONT.XFE_E.XP.n37 XFRONT.XFE_E.XP.t39 109.174
R6331 XFRONT.XFE_E.XP.t42 XFRONT.XFE_E.XP.n38 109.174
R6332 XFRONT.XFE_E.XP.n42 XFRONT.XFE_E.XP.t41 109.174
R6333 XFRONT.XFE_E.XP.t40 XFRONT.XFE_E.XP.n43 109.174
R6334 XFRONT.XFE_E.XP.n29 XFRONT.XFE_E.XP.t33 109.174
R6335 XFRONT.XFE_E.XP.n30 XFRONT.XFE_E.XP.t34 109.174
R6336 XFRONT.XFE_E.XP.n31 XFRONT.XFE_E.XP.t35 109.174
R6337 XFRONT.XFE_E.XP.n32 XFRONT.XFE_E.XP.t36 109.174
R6338 XFRONT.XFE_E.XP.n33 XFRONT.XFE_E.XP.t37 109.174
R6339 XFRONT.XFE_E.XP.t38 XFRONT.XFE_E.XP.n18 109.174
R6340 XFRONT.XFE_E.XP.n13 XFRONT.XFE_E.XP.t55 109.174
R6341 XFRONT.XFE_E.XP.n12 XFRONT.XFE_E.XP.t54 109.174
R6342 XFRONT.XFE_E.XP.n11 XFRONT.XFE_E.XP.t53 109.174
R6343 XFRONT.XFE_E.XP.n48 XFRONT.XFE_E.XP.n47 26.8696
R6344 XFRONT.XFE_E.XP.n72 XFRONT.XFE_E.XP.n71 22.8718
R6345 XFRONT.XFE_E.XP.n46 XFRONT.XFE_E.XP.n14 20.2802
R6346 XFRONT.XFE_E.XP.n78 XFRONT.XFE_E.XP.n77 18.5179
R6347 XFRONT.XFE_E.XP.n76 XFRONT.XFE_E.XP.n73 18.4942
R6348 XFRONT.XFE_E.XP.n37 XFRONT.XFE_E.XP.n36 18.4942
R6349 XFRONT.XFE_E.XP.n42 XFRONT.XFE_E.XP.n41 18.4942
R6350 XFRONT.XFE_E.XP.n43 XFRONT.XFE_E.XP.n15 18.4942
R6351 XFRONT.XFE_E.XP.n30 XFRONT.XFE_E.XP.n21 18.4942
R6352 XFRONT.XFE_E.XP.n31 XFRONT.XFE_E.XP.n20 18.4942
R6353 XFRONT.XFE_E.XP.n32 XFRONT.XFE_E.XP.n19 18.4942
R6354 XFRONT.XFE_E.XP.n34 XFRONT.XFE_E.XP.n33 18.4942
R6355 XFRONT.XFE_E.XP.n35 XFRONT.XFE_E.XP.n18 18.4942
R6356 XFRONT.XFE_E.XP.n14 XFRONT.XFE_E.XP.n13 18.4942
R6357 XFRONT.XFE_E.XP.n12 XFRONT.XFE_E.XP.n9 18.4942
R6358 XFRONT.XFE_E.XP.n58 XFRONT.XFE_E.XP.n57 16.6309
R6359 XFRONT.XFE_E.XP.n79 XFRONT.XFE_E.XP.n78 14.8896
R6360 XFRONT.XFE_E.XP XFRONT.XFE_E.XP.n8 14.3222
R6361 XFRONT.XFE_E.XP.n56 XFRONT.XFE_E.XP.n55 14.2831
R6362 XFRONT.XFE_E.XP.n70 XFRONT.XFE_E.XP.n69 11.7396
R6363 XFRONT.XFE_E.XP.n76 XFRONT.XFE_E.XP.n75 11.6805
R6364 XFRONT.XFE_E.XP.n77 XFRONT.XFE_E.XP.n76 11.6805
R6365 XFRONT.XFE_E.XP.n43 XFRONT.XFE_E.XP.n42 11.6805
R6366 XFRONT.XFE_E.XP.n42 XFRONT.XFE_E.XP.n38 11.6805
R6367 XFRONT.XFE_E.XP.n43 XFRONT.XFE_E.XP.n37 11.6805
R6368 XFRONT.XFE_E.XP.n30 XFRONT.XFE_E.XP.n29 11.6805
R6369 XFRONT.XFE_E.XP.n31 XFRONT.XFE_E.XP.n30 11.6805
R6370 XFRONT.XFE_E.XP.n32 XFRONT.XFE_E.XP.n31 11.6805
R6371 XFRONT.XFE_E.XP.n33 XFRONT.XFE_E.XP.n32 11.6805
R6372 XFRONT.XFE_E.XP.n33 XFRONT.XFE_E.XP.n18 11.6805
R6373 XFRONT.XFE_E.XP.n37 XFRONT.XFE_E.XP.n18 11.6805
R6374 XFRONT.XFE_E.XP.n13 XFRONT.XFE_E.XP.n12 11.6805
R6375 XFRONT.XFE_E.XP.n12 XFRONT.XFE_E.XP.n11 11.6805
R6376 XFRONT.XFE_E.XP.n45 XFRONT.XFE_E.XP.n15 10.8396
R6377 XFRONT.XFE_E.XP.n45 XFRONT.XFE_E.XP.n44 9.0005
R6378 XFRONT.XFE_E.XP.n74 XFRONT.XFE_E.XP.n73 7.17687
R6379 XFRONT.XFE_E.XP.n41 XFRONT.XFE_E.XP.n40 7.17687
R6380 XFRONT.XFE_E.XP.n28 XFRONT.XFE_E.XP.n21 7.17687
R6381 XFRONT.XFE_E.XP.n10 XFRONT.XFE_E.XP.n9 7.17687
R6382 XFRONT.XFE_E.XP.n46 XFRONT.XFE_E.XP.n45 6.94615
R6383 XFRONT.XFE_E.XP.n60 XFRONT.XFE_E.XP.t29 5.7796
R6384 XFRONT.XFE_E.XP.n64 XFRONT.XFE_E.XP.t18 5.7796
R6385 XFRONT.XFE_E.XP.n1 XFRONT.XFE_E.XP.t8 5.73764
R6386 XFRONT.XFE_E.XP.n50 XFRONT.XFE_E.XP.t7 5.73764
R6387 XFRONT.XFE_E.XP.n52 XFRONT.XFE_E.XP.t0 5.73764
R6388 XFRONT.XFE_E.XP.n57 XFRONT.XFE_E.XP.t31 5.66659
R6389 XFRONT.XFE_E.XP.n57 XFRONT.XFE_E.XP.t30 5.61922
R6390 XFRONT.XFE_E.XP.n8 XFRONT.XFE_E.XP.t17 5.57185
R6391 XFRONT.XFE_E.XP.n60 XFRONT.XFE_E.XP.n59 5.38537
R6392 XFRONT.XFE_E.XP.n62 XFRONT.XFE_E.XP.n61 5.38537
R6393 XFRONT.XFE_E.XP.n68 XFRONT.XFE_E.XP.n67 5.38537
R6394 XFRONT.XFE_E.XP.n66 XFRONT.XFE_E.XP.n65 5.38537
R6395 XFRONT.XFE_E.XP.n64 XFRONT.XFE_E.XP.n63 5.38537
R6396 XFRONT.XFE_E.XP.n7 XFRONT.XFE_E.XP.n6 5.32067
R6397 XFRONT.XFE_E.XP.n5 XFRONT.XFE_E.XP.n4 5.32067
R6398 XFRONT.XFE_E.XP.n3 XFRONT.XFE_E.XP.n2 5.32067
R6399 XFRONT.XFE_E.XP.n1 XFRONT.XFE_E.XP.n0 5.32067
R6400 XFRONT.XFE_E.XP.n50 XFRONT.XFE_E.XP.n49 5.32067
R6401 XFRONT.XFE_E.XP.n54 XFRONT.XFE_E.XP.n53 5.32067
R6402 XFRONT.XFE_E.XP.n52 XFRONT.XFE_E.XP.n51 5.32067
R6403 XFRONT.XFE_E.XP.n75 XFRONT.XFE_E.XP.n74 4.42851
R6404 XFRONT.XFE_E.XP.n40 XFRONT.XFE_E.XP.n38 4.42851
R6405 XFRONT.XFE_E.XP.n29 XFRONT.XFE_E.XP.n28 4.42851
R6406 XFRONT.XFE_E.XP.n11 XFRONT.XFE_E.XP.n10 4.42851
R6407 XFRONT.XFE_E.XP.n48 XFRONT.XFE_E.XP.n46 3.71789
R6408 XFRONT.XFE_E.XP.n70 XFRONT.XFE_E.XP.n58 3.13093
R6409 XFRONT.XFE_E.XP.n58 XFRONT.XFE_E.XP.n56 1.76137
R6410 XFRONT.XFE_E.XP.n56 XFRONT.XFE_E.XP.n48 1.72224
R6411 XFRONT.XFE_E.XP XFRONT.XFE_E.XP.n79 1.2918
R6412 XFRONT.XFE_E.XP.n72 XFRONT.XFE_E.XP.n70 1.01789
R6413 XFRONT.XFE_E.XP.n79 XFRONT.XFE_E.XP.n72 0.391804
R6414 XFRONT.XFE_E.XP.n6 XFRONT.XFE_E.XP.t15 0.228
R6415 XFRONT.XFE_E.XP.n6 XFRONT.XFE_E.XP.t16 0.228
R6416 XFRONT.XFE_E.XP.n4 XFRONT.XFE_E.XP.t13 0.228
R6417 XFRONT.XFE_E.XP.n4 XFRONT.XFE_E.XP.t14 0.228
R6418 XFRONT.XFE_E.XP.n2 XFRONT.XFE_E.XP.t11 0.228
R6419 XFRONT.XFE_E.XP.n2 XFRONT.XFE_E.XP.t12 0.228
R6420 XFRONT.XFE_E.XP.n0 XFRONT.XFE_E.XP.t9 0.228
R6421 XFRONT.XFE_E.XP.n0 XFRONT.XFE_E.XP.t10 0.228
R6422 XFRONT.XFE_E.XP.n49 XFRONT.XFE_E.XP.t5 0.228
R6423 XFRONT.XFE_E.XP.n49 XFRONT.XFE_E.XP.t6 0.228
R6424 XFRONT.XFE_E.XP.n53 XFRONT.XFE_E.XP.t3 0.228
R6425 XFRONT.XFE_E.XP.n53 XFRONT.XFE_E.XP.t4 0.228
R6426 XFRONT.XFE_E.XP.n51 XFRONT.XFE_E.XP.t1 0.228
R6427 XFRONT.XFE_E.XP.n51 XFRONT.XFE_E.XP.t2 0.228
R6428 XFRONT.XFE_E.XP.n59 XFRONT.XFE_E.XP.t27 0.20525
R6429 XFRONT.XFE_E.XP.n59 XFRONT.XFE_E.XP.t28 0.20525
R6430 XFRONT.XFE_E.XP.n61 XFRONT.XFE_E.XP.t25 0.20525
R6431 XFRONT.XFE_E.XP.n61 XFRONT.XFE_E.XP.t26 0.20525
R6432 XFRONT.XFE_E.XP.n67 XFRONT.XFE_E.XP.t23 0.20525
R6433 XFRONT.XFE_E.XP.n67 XFRONT.XFE_E.XP.t24 0.20525
R6434 XFRONT.XFE_E.XP.n65 XFRONT.XFE_E.XP.t21 0.20525
R6435 XFRONT.XFE_E.XP.n65 XFRONT.XFE_E.XP.t22 0.20525
R6436 XFRONT.XFE_E.XP.n63 XFRONT.XFE_E.XP.t19 0.20525
R6437 XFRONT.XFE_E.XP.n63 XFRONT.XFE_E.XP.t20 0.20525
R6438 XFRONT.XFE_E.XP.n66 XFRONT.XFE_E.XP.n64 0.189974
R6439 XFRONT.XFE_E.XP.n68 XFRONT.XFE_E.XP.n66 0.189974
R6440 XFRONT.XFE_E.XP.n62 XFRONT.XFE_E.XP.n60 0.189974
R6441 XFRONT.XFE_E.XP.n3 XFRONT.XFE_E.XP.n1 0.189974
R6442 XFRONT.XFE_E.XP.n5 XFRONT.XFE_E.XP.n3 0.189974
R6443 XFRONT.XFE_E.XP.n7 XFRONT.XFE_E.XP.n5 0.189974
R6444 XFRONT.XFE_E.XP.n54 XFRONT.XFE_E.XP.n52 0.189974
R6445 XFRONT.XFE_E.XP.n8 XFRONT.XFE_E.XP.n7 0.166289
R6446 XFRONT.XFE_E.XP.n36 XFRONT.XFE_E.XP.n35 0.1205
R6447 XFRONT.XFE_E.XP.n35 XFRONT.XFE_E.XP.n34 0.1205
R6448 XFRONT.XFE_E.XP.n34 XFRONT.XFE_E.XP.n19 0.1205
R6449 XFRONT.XFE_E.XP.n20 XFRONT.XFE_E.XP.n19 0.1205
R6450 XFRONT.XFE_E.XP.n21 XFRONT.XFE_E.XP.n20 0.1205
R6451 XFRONT.XFE_E.XP.n22 XFRONT.XFE_E.XP.n16 0.1205
R6452 XFRONT.XFE_E.XP.n23 XFRONT.XFE_E.XP.n22 0.1205
R6453 XFRONT.XFE_E.XP.n24 XFRONT.XFE_E.XP.n23 0.1205
R6454 XFRONT.XFE_E.XP.n25 XFRONT.XFE_E.XP.n24 0.1205
R6455 XFRONT.XFE_E.XP.n26 XFRONT.XFE_E.XP.n25 0.1205
R6456 XFRONT.XFE_E.XP.n27 XFRONT.XFE_E.XP.n26 0.1205
R6457 XFRONT.XFE_E.XP.n39 XFRONT.XFE_E.XP.n17 0.1205
R6458 XFRONT.XFE_E.XP.n14 XFRONT.XFE_E.XP.n9 0.1205
R6459 XFRONT.XFE_E.XP.n36 XFRONT.XFE_E.XP.n15 0.1085
R6460 XFRONT.XFE_E.XP.n44 XFRONT.XFE_E.XP.n16 0.1085
R6461 XFRONT.XFE_E.XP.n44 XFRONT.XFE_E.XP.n17 0.1085
R6462 XFRONT.XFE_E.XP.n41 XFRONT.XFE_E.XP.n15 0.1085
R6463 XFRONT.XFE_E.XP.n69 XFRONT.XFE_E.XP.n68 0.0952368
R6464 XFRONT.XFE_E.XP.n69 XFRONT.XFE_E.XP.n62 0.0952368
R6465 XFRONT.XFE_E.XP.n55 XFRONT.XFE_E.XP.n54 0.0952368
R6466 XFRONT.XFE_E.XP.n55 XFRONT.XFE_E.XP.n50 0.0952368
R6467 XFRONT.XFE_E.XP.n78 XFRONT.XFE_E.XP.n73 0.0785
R6468 XCAP.O_RST_TAIL.n10 XCAP.O_RST_TAIL.n2 15.9369
R6469 XCAP.O_RST_TAIL.n10 XCAP.O_RST_TAIL.n9 10.957
R6470 XCAP.O_RST_TAIL.n4 XCAP.O_RST_TAIL.t11 5.7796
R6471 XCAP.O_RST_TAIL.n9 XCAP.O_RST_TAIL.t4 5.68486
R6472 XCAP.O_RST_TAIL.n2 XCAP.O_RST_TAIL.n0 5.57485
R6473 XCAP.O_RST_TAIL.n4 XCAP.O_RST_TAIL.n3 5.38537
R6474 XCAP.O_RST_TAIL.n2 XCAP.O_RST_TAIL.n1 5.38537
R6475 XCAP.O_RST_TAIL.n6 XCAP.O_RST_TAIL.n5 5.38537
R6476 XCAP.O_RST_TAIL.n8 XCAP.O_RST_TAIL.n7 5.38537
R6477 XCAP.O_RST_TAIL.n3 XCAP.O_RST_TAIL.t9 0.20525
R6478 XCAP.O_RST_TAIL.n3 XCAP.O_RST_TAIL.t10 0.20525
R6479 XCAP.O_RST_TAIL.n1 XCAP.O_RST_TAIL.t1 0.20525
R6480 XCAP.O_RST_TAIL.n1 XCAP.O_RST_TAIL.t3 0.20525
R6481 XCAP.O_RST_TAIL.n0 XCAP.O_RST_TAIL.t0 0.20525
R6482 XCAP.O_RST_TAIL.n0 XCAP.O_RST_TAIL.t2 0.20525
R6483 XCAP.O_RST_TAIL.n5 XCAP.O_RST_TAIL.t7 0.20525
R6484 XCAP.O_RST_TAIL.n5 XCAP.O_RST_TAIL.t8 0.20525
R6485 XCAP.O_RST_TAIL.n7 XCAP.O_RST_TAIL.t5 0.20525
R6486 XCAP.O_RST_TAIL.n7 XCAP.O_RST_TAIL.t6 0.20525
R6487 XCAP.O_RST_TAIL.n8 XCAP.O_RST_TAIL.n6 0.189974
R6488 XCAP.O_RST_TAIL.n6 XCAP.O_RST_TAIL.n4 0.189974
R6489 XCAP.O_RST_TAIL.n9 XCAP.O_RST_TAIL.n8 0.0952368
R6490 XCAP.O_RST_TAIL XCAP.O_RST_TAIL.n10 0.0396304
R6491 XCAP.E_RST_TAIL.n10 XCAP.E_RST_TAIL.n9 11.9456
R6492 XCAP.E_RST_TAIL.n10 XCAP.E_RST_TAIL.n6 11.6614
R6493 XCAP.E_RST_TAIL.n1 XCAP.E_RST_TAIL.t9 5.7796
R6494 XCAP.E_RST_TAIL.n6 XCAP.E_RST_TAIL.t2 5.68486
R6495 XCAP.E_RST_TAIL.n9 XCAP.E_RST_TAIL.n7 5.57485
R6496 XCAP.E_RST_TAIL.n9 XCAP.E_RST_TAIL.n8 5.38537
R6497 XCAP.E_RST_TAIL.n1 XCAP.E_RST_TAIL.n0 5.38537
R6498 XCAP.E_RST_TAIL.n3 XCAP.E_RST_TAIL.n2 5.38537
R6499 XCAP.E_RST_TAIL.n5 XCAP.E_RST_TAIL.n4 5.38537
R6500 XCAP.E_RST_TAIL.n8 XCAP.E_RST_TAIL.t10 0.20525
R6501 XCAP.E_RST_TAIL.n8 XCAP.E_RST_TAIL.t1 0.20525
R6502 XCAP.E_RST_TAIL.n7 XCAP.E_RST_TAIL.t0 0.20525
R6503 XCAP.E_RST_TAIL.n7 XCAP.E_RST_TAIL.t11 0.20525
R6504 XCAP.E_RST_TAIL.n0 XCAP.E_RST_TAIL.t7 0.20525
R6505 XCAP.E_RST_TAIL.n0 XCAP.E_RST_TAIL.t8 0.20525
R6506 XCAP.E_RST_TAIL.n2 XCAP.E_RST_TAIL.t5 0.20525
R6507 XCAP.E_RST_TAIL.n2 XCAP.E_RST_TAIL.t6 0.20525
R6508 XCAP.E_RST_TAIL.n4 XCAP.E_RST_TAIL.t3 0.20525
R6509 XCAP.E_RST_TAIL.n4 XCAP.E_RST_TAIL.t4 0.20525
R6510 XCAP.E_RST_TAIL.n5 XCAP.E_RST_TAIL.n3 0.189974
R6511 XCAP.E_RST_TAIL.n3 XCAP.E_RST_TAIL.n1 0.189974
R6512 XCAP.E_RST_TAIL.n6 XCAP.E_RST_TAIL.n5 0.0952368
R6513 XCAP.E_RST_TAIL XCAP.E_RST_TAIL.n10 0.0396304
R6514 XCAP.O_SET_TAIL.n9 XCAP.O_SET_TAIL.n5 11.3875
R6515 XCAP.O_SET_TAIL.n9 XCAP.O_SET_TAIL.n8 9.68219
R6516 XCAP.O_SET_TAIL.n1 XCAP.O_SET_TAIL.t11 5.7796
R6517 XCAP.O_SET_TAIL.n5 XCAP.O_SET_TAIL.t4 5.7796
R6518 XCAP.O_SET_TAIL.n8 XCAP.O_SET_TAIL.n6 5.57485
R6519 XCAP.O_SET_TAIL.n1 XCAP.O_SET_TAIL.n0 5.38537
R6520 XCAP.O_SET_TAIL.n3 XCAP.O_SET_TAIL.n2 5.38537
R6521 XCAP.O_SET_TAIL.n8 XCAP.O_SET_TAIL.n7 5.38537
R6522 XCAP.O_SET_TAIL.n5 XCAP.O_SET_TAIL.n4 5.38537
R6523 XCAP.O_SET_TAIL.n0 XCAP.O_SET_TAIL.t9 0.20525
R6524 XCAP.O_SET_TAIL.n0 XCAP.O_SET_TAIL.t10 0.20525
R6525 XCAP.O_SET_TAIL.n2 XCAP.O_SET_TAIL.t7 0.20525
R6526 XCAP.O_SET_TAIL.n2 XCAP.O_SET_TAIL.t8 0.20525
R6527 XCAP.O_SET_TAIL.n7 XCAP.O_SET_TAIL.t2 0.20525
R6528 XCAP.O_SET_TAIL.n7 XCAP.O_SET_TAIL.t0 0.20525
R6529 XCAP.O_SET_TAIL.n6 XCAP.O_SET_TAIL.t1 0.20525
R6530 XCAP.O_SET_TAIL.n6 XCAP.O_SET_TAIL.t3 0.20525
R6531 XCAP.O_SET_TAIL.n4 XCAP.O_SET_TAIL.t5 0.20525
R6532 XCAP.O_SET_TAIL.n4 XCAP.O_SET_TAIL.t6 0.20525
R6533 XCAP.O_SET_TAIL.n5 XCAP.O_SET_TAIL.n3 0.189974
R6534 XCAP.O_SET_TAIL.n3 XCAP.O_SET_TAIL.n1 0.189974
R6535 XCAP.O_SET_TAIL XCAP.O_SET_TAIL.n9 0.0396304
R6536 XCAP.E_SET_TAIL.n9 XCAP.E_SET_TAIL.n2 12.1083
R6537 XCAP.E_SET_TAIL.n9 XCAP.E_SET_TAIL.n8 10.2135
R6538 XCAP.E_SET_TAIL.n4 XCAP.E_SET_TAIL.t11 5.7796
R6539 XCAP.E_SET_TAIL.n8 XCAP.E_SET_TAIL.t4 5.7796
R6540 XCAP.E_SET_TAIL.n2 XCAP.E_SET_TAIL.n0 5.57485
R6541 XCAP.E_SET_TAIL.n4 XCAP.E_SET_TAIL.n3 5.38537
R6542 XCAP.E_SET_TAIL.n6 XCAP.E_SET_TAIL.n5 5.38537
R6543 XCAP.E_SET_TAIL.n2 XCAP.E_SET_TAIL.n1 5.38537
R6544 XCAP.E_SET_TAIL.n8 XCAP.E_SET_TAIL.n7 5.38537
R6545 XCAP.E_SET_TAIL.n3 XCAP.E_SET_TAIL.t9 0.20525
R6546 XCAP.E_SET_TAIL.n3 XCAP.E_SET_TAIL.t10 0.20525
R6547 XCAP.E_SET_TAIL.n5 XCAP.E_SET_TAIL.t7 0.20525
R6548 XCAP.E_SET_TAIL.n5 XCAP.E_SET_TAIL.t8 0.20525
R6549 XCAP.E_SET_TAIL.n1 XCAP.E_SET_TAIL.t1 0.20525
R6550 XCAP.E_SET_TAIL.n1 XCAP.E_SET_TAIL.t0 0.20525
R6551 XCAP.E_SET_TAIL.n0 XCAP.E_SET_TAIL.t3 0.20525
R6552 XCAP.E_SET_TAIL.n0 XCAP.E_SET_TAIL.t2 0.20525
R6553 XCAP.E_SET_TAIL.n7 XCAP.E_SET_TAIL.t5 0.20525
R6554 XCAP.E_SET_TAIL.n7 XCAP.E_SET_TAIL.t6 0.20525
R6555 XCAP.E_SET_TAIL.n8 XCAP.E_SET_TAIL.n6 0.189974
R6556 XCAP.E_SET_TAIL.n6 XCAP.E_SET_TAIL.n4 0.189974
R6557 XCAP.E_SET_TAIL XCAP.E_SET_TAIL.n9 0.0396304
R6558 XCAP.O_PSET_TAIL.n10 XCAP.O_PSET_TAIL.n2 15.7351
R6559 XCAP.O_PSET_TAIL.n10 XCAP.O_PSET_TAIL.n9 12.6005
R6560 XCAP.O_PSET_TAIL.n4 XCAP.O_PSET_TAIL.t11 5.73764
R6561 XCAP.O_PSET_TAIL.n9 XCAP.O_PSET_TAIL.t4 5.54817
R6562 XCAP.O_PSET_TAIL.n2 XCAP.O_PSET_TAIL.n0 5.51014
R6563 XCAP.O_PSET_TAIL.n4 XCAP.O_PSET_TAIL.n3 5.32067
R6564 XCAP.O_PSET_TAIL.n6 XCAP.O_PSET_TAIL.n5 5.32067
R6565 XCAP.O_PSET_TAIL.n8 XCAP.O_PSET_TAIL.n7 5.32067
R6566 XCAP.O_PSET_TAIL.n2 XCAP.O_PSET_TAIL.n1 5.32067
R6567 XCAP.O_PSET_TAIL.n3 XCAP.O_PSET_TAIL.t9 0.228
R6568 XCAP.O_PSET_TAIL.n3 XCAP.O_PSET_TAIL.t10 0.228
R6569 XCAP.O_PSET_TAIL.n5 XCAP.O_PSET_TAIL.t7 0.228
R6570 XCAP.O_PSET_TAIL.n5 XCAP.O_PSET_TAIL.t8 0.228
R6571 XCAP.O_PSET_TAIL.n7 XCAP.O_PSET_TAIL.t5 0.228
R6572 XCAP.O_PSET_TAIL.n7 XCAP.O_PSET_TAIL.t6 0.228
R6573 XCAP.O_PSET_TAIL.n1 XCAP.O_PSET_TAIL.t0 0.228
R6574 XCAP.O_PSET_TAIL.n1 XCAP.O_PSET_TAIL.t3 0.228
R6575 XCAP.O_PSET_TAIL.n0 XCAP.O_PSET_TAIL.t2 0.228
R6576 XCAP.O_PSET_TAIL.n0 XCAP.O_PSET_TAIL.t1 0.228
R6577 XCAP.O_PSET_TAIL.n9 XCAP.O_PSET_TAIL.n8 0.189974
R6578 XCAP.O_PSET_TAIL.n8 XCAP.O_PSET_TAIL.n6 0.189974
R6579 XCAP.O_PSET_TAIL.n6 XCAP.O_PSET_TAIL.n4 0.189974
R6580 XCAP.O_PSET_TAIL XCAP.O_PSET_TAIL.n10 0.0396304
R6581 XCAP.E_PSET_TAIL.n10 XCAP.E_PSET_TAIL.n6 15.4962
R6582 XCAP.E_PSET_TAIL.n10 XCAP.E_PSET_TAIL.n9 12.1804
R6583 XCAP.E_PSET_TAIL.n1 XCAP.E_PSET_TAIL.t11 5.73764
R6584 XCAP.E_PSET_TAIL.n6 XCAP.E_PSET_TAIL.t4 5.54817
R6585 XCAP.E_PSET_TAIL.n9 XCAP.E_PSET_TAIL.n7 5.51014
R6586 XCAP.E_PSET_TAIL.n1 XCAP.E_PSET_TAIL.n0 5.32067
R6587 XCAP.E_PSET_TAIL.n3 XCAP.E_PSET_TAIL.n2 5.32067
R6588 XCAP.E_PSET_TAIL.n5 XCAP.E_PSET_TAIL.n4 5.32067
R6589 XCAP.E_PSET_TAIL.n9 XCAP.E_PSET_TAIL.n8 5.32067
R6590 XCAP.E_PSET_TAIL.n0 XCAP.E_PSET_TAIL.t9 0.228
R6591 XCAP.E_PSET_TAIL.n0 XCAP.E_PSET_TAIL.t10 0.228
R6592 XCAP.E_PSET_TAIL.n2 XCAP.E_PSET_TAIL.t7 0.228
R6593 XCAP.E_PSET_TAIL.n2 XCAP.E_PSET_TAIL.t8 0.228
R6594 XCAP.E_PSET_TAIL.n4 XCAP.E_PSET_TAIL.t5 0.228
R6595 XCAP.E_PSET_TAIL.n4 XCAP.E_PSET_TAIL.t6 0.228
R6596 XCAP.E_PSET_TAIL.n7 XCAP.E_PSET_TAIL.t0 0.228
R6597 XCAP.E_PSET_TAIL.n7 XCAP.E_PSET_TAIL.t2 0.228
R6598 XCAP.E_PSET_TAIL.n8 XCAP.E_PSET_TAIL.t3 0.228
R6599 XCAP.E_PSET_TAIL.n8 XCAP.E_PSET_TAIL.t1 0.228
R6600 XCAP.E_PSET_TAIL.n6 XCAP.E_PSET_TAIL.n5 0.189974
R6601 XCAP.E_PSET_TAIL.n5 XCAP.E_PSET_TAIL.n3 0.189974
R6602 XCAP.E_PSET_TAIL.n3 XCAP.E_PSET_TAIL.n1 0.189974
R6603 XCAP.E_PSET_TAIL XCAP.E_PSET_TAIL.n10 0.0396304
R6604 XCAP.O_QI.n0 XCAP.O_QI.t19 113.632
R6605 XCAP.O_QI.n16 XCAP.O_QI.t12 113.618
R6606 XCAP.O_QI.n16 XCAP.O_QI.t13 113.618
R6607 XCAP.O_QI.n15 XCAP.O_QI.t16 113.618
R6608 XCAP.O_QI.n15 XCAP.O_QI.t17 113.618
R6609 XCAP.O_QI.n0 XCAP.O_QI.t18 113.603
R6610 XCAP.O_QI.n1 XCAP.O_QI.t15 61.4885
R6611 XCAP.O_QI.n1 XCAP.O_QI.t14 61.4598
R6612 XCAP.O_QI.n2 XCAP.O_QI.n0 21.3118
R6613 XCAP.O_QI.n17 XCAP.O_QI.n15 19.4852
R6614 XCAP.O_QI.n17 XCAP.O_QI.n16 17.5287
R6615 XCAP.O_QI.n2 XCAP.O_QI.n1 16.2249
R6616 XCAP.O_QI.n14 XCAP.O_QI.n2 10.9375
R6617 XCAP.O_QI.n13 XCAP.O_QI.n12 9.70485
R6618 XCAP.O_QI.n7 XCAP.O_QI.n5 7.43528
R6619 XCAP.O_QI.n11 XCAP.O_QI.t11 5.7796
R6620 XCAP.O_QI.n8 XCAP.O_QI.t3 5.7796
R6621 XCAP.O_QI.n6 XCAP.O_QI.t9 5.73764
R6622 XCAP.O_QI.n4 XCAP.O_QI.t6 5.73764
R6623 XCAP.O_QI.n12 XCAP.O_QI.t5 5.68486
R6624 XCAP.O_QI.n5 XCAP.O_QI.t2 5.6429
R6625 XCAP.O_QI.n8 XCAP.O_QI.t4 5.59012
R6626 XCAP.O_QI.n6 XCAP.O_QI.t10 5.54817
R6627 XCAP.O_QI.n11 XCAP.O_QI.n10 5.38537
R6628 XCAP.O_QI.n4 XCAP.O_QI.n3 5.32067
R6629 XCAP.O_QI.n9 XCAP.O_QI.n7 4.8918
R6630 XCAP.O_QI.n7 XCAP.O_QI.n6 4.5005
R6631 XCAP.O_QI.n9 XCAP.O_QI.n8 4.5005
R6632 XCAP.O_QI.n14 XCAP.O_QI.n13 4.5005
R6633 XCAP.O_QI.n18 XCAP.O_QI.n17 4.5005
R6634 XCAP.O_QI.n18 XCAP.O_QI.n14 2.1918
R6635 XCAP.O_QI.n3 XCAP.O_QI.t1 0.228
R6636 XCAP.O_QI.n3 XCAP.O_QI.t0 0.228
R6637 XCAP.O_QI.n10 XCAP.O_QI.t8 0.20525
R6638 XCAP.O_QI.n10 XCAP.O_QI.t7 0.20525
R6639 XCAP.O_QI.n5 XCAP.O_QI.n4 0.0952368
R6640 XCAP.O_QI.n12 XCAP.O_QI.n11 0.0952368
R6641 XCAP.O_QI.n13 XCAP.O_QI.n9 0.0787609
R6642 XCAP.O_QI XCAP.O_QI.n18 0.0396304
R6643 XCAP.ODD_DB_BUF.n18 XCAP.ODD_DB_BUF.t12 113.632
R6644 XCAP.ODD_DB_BUF.n12 XCAP.ODD_DB_BUF.t16 113.632
R6645 XCAP.ODD_DB_BUF.n21 XCAP.ODD_DB_BUF.t15 109.174
R6646 XCAP.ODD_DB_BUF.n20 XCAP.ODD_DB_BUF.t14 109.174
R6647 XCAP.ODD_DB_BUF.n19 XCAP.ODD_DB_BUF.t13 109.174
R6648 XCAP.ODD_DB_BUF.n13 XCAP.ODD_DB_BUF.t17 109.174
R6649 XCAP.ODD_DB_BUF.n14 XCAP.ODD_DB_BUF.t18 109.174
R6650 XCAP.ODD_DB_BUF.n15 XCAP.ODD_DB_BUF.t19 109.174
R6651 XCAP.ODD_DB_BUF.n23 XCAP.ODD_DB_BUF.n22 21.6707
R6652 XCAP.ODD_DB_BUF.n22 XCAP.ODD_DB_BUF.n21 18.4942
R6653 XCAP.ODD_DB_BUF.n20 XCAP.ODD_DB_BUF.n17 18.4942
R6654 XCAP.ODD_DB_BUF.n14 XCAP.ODD_DB_BUF.n11 18.4942
R6655 XCAP.ODD_DB_BUF.n16 XCAP.ODD_DB_BUF.n15 18.4942
R6656 XCAP.ODD_DB_BUF.n21 XCAP.ODD_DB_BUF.n20 11.6805
R6657 XCAP.ODD_DB_BUF.n20 XCAP.ODD_DB_BUF.n19 11.6805
R6658 XCAP.ODD_DB_BUF.n14 XCAP.ODD_DB_BUF.n13 11.6805
R6659 XCAP.ODD_DB_BUF.n15 XCAP.ODD_DB_BUF.n14 11.6805
R6660 XCAP.ODD_DB_BUF.n10 XCAP.ODD_DB_BUF.n2 10.3701
R6661 XCAP.ODD_DB_BUF.n23 XCAP.ODD_DB_BUF.n16 9.77502
R6662 XCAP.ODD_DB_BUF.n24 XCAP.ODD_DB_BUF.n10 7.94398
R6663 XCAP.ODD_DB_BUF.n18 XCAP.ODD_DB_BUF.n17 7.17687
R6664 XCAP.ODD_DB_BUF.n12 XCAP.ODD_DB_BUF.n11 7.17687
R6665 XCAP.ODD_DB_BUF.n1 XCAP.ODD_DB_BUF.t11 5.7796
R6666 XCAP.ODD_DB_BUF.n4 XCAP.ODD_DB_BUF.t7 5.73764
R6667 XCAP.ODD_DB_BUF.n8 XCAP.ODD_DB_BUF.t0 5.73764
R6668 XCAP.ODD_DB_BUF.n2 XCAP.ODD_DB_BUF.t8 5.68486
R6669 XCAP.ODD_DB_BUF.n1 XCAP.ODD_DB_BUF.n0 5.38537
R6670 XCAP.ODD_DB_BUF.n4 XCAP.ODD_DB_BUF.n3 5.32067
R6671 XCAP.ODD_DB_BUF.n6 XCAP.ODD_DB_BUF.n5 5.32067
R6672 XCAP.ODD_DB_BUF.n8 XCAP.ODD_DB_BUF.n7 5.32067
R6673 XCAP.ODD_DB_BUF.n10 XCAP.ODD_DB_BUF.n9 4.5005
R6674 XCAP.ODD_DB_BUF.n24 XCAP.ODD_DB_BUF.n23 4.5005
R6675 XCAP.ODD_DB_BUF.n19 XCAP.ODD_DB_BUF.n18 4.42851
R6676 XCAP.ODD_DB_BUF.n13 XCAP.ODD_DB_BUF.n12 4.42851
R6677 XCAP.ODD_DB_BUF.n3 XCAP.ODD_DB_BUF.t5 0.228
R6678 XCAP.ODD_DB_BUF.n3 XCAP.ODD_DB_BUF.t6 0.228
R6679 XCAP.ODD_DB_BUF.n5 XCAP.ODD_DB_BUF.t3 0.228
R6680 XCAP.ODD_DB_BUF.n5 XCAP.ODD_DB_BUF.t4 0.228
R6681 XCAP.ODD_DB_BUF.n7 XCAP.ODD_DB_BUF.t1 0.228
R6682 XCAP.ODD_DB_BUF.n7 XCAP.ODD_DB_BUF.t2 0.228
R6683 XCAP.ODD_DB_BUF.n0 XCAP.ODD_DB_BUF.t9 0.20525
R6684 XCAP.ODD_DB_BUF.n0 XCAP.ODD_DB_BUF.t10 0.20525
R6685 XCAP.ODD_DB_BUF.n6 XCAP.ODD_DB_BUF.n4 0.189974
R6686 XCAP.ODD_DB_BUF.n22 XCAP.ODD_DB_BUF.n17 0.1205
R6687 XCAP.ODD_DB_BUF.n16 XCAP.ODD_DB_BUF.n11 0.1205
R6688 XCAP.ODD_DB_BUF.n9 XCAP.ODD_DB_BUF.n8 0.0952368
R6689 XCAP.ODD_DB_BUF.n9 XCAP.ODD_DB_BUF.n6 0.0952368
R6690 XCAP.ODD_DB_BUF.n2 XCAP.ODD_DB_BUF.n1 0.0952368
R6691 XCAP.ODD_DB_BUF XCAP.ODD_DB_BUF.n24 0.0396304
R6692 XCAP.EVEN_DB_BUF.n7 XCAP.EVEN_DB_BUF.t12 113.632
R6693 XCAP.EVEN_DB_BUF.n1 XCAP.EVEN_DB_BUF.t16 113.632
R6694 XCAP.EVEN_DB_BUF.n10 XCAP.EVEN_DB_BUF.t15 109.174
R6695 XCAP.EVEN_DB_BUF.n9 XCAP.EVEN_DB_BUF.t14 109.174
R6696 XCAP.EVEN_DB_BUF.n8 XCAP.EVEN_DB_BUF.t13 109.174
R6697 XCAP.EVEN_DB_BUF.n2 XCAP.EVEN_DB_BUF.t17 109.174
R6698 XCAP.EVEN_DB_BUF.n3 XCAP.EVEN_DB_BUF.t18 109.174
R6699 XCAP.EVEN_DB_BUF.n4 XCAP.EVEN_DB_BUF.t19 109.174
R6700 XCAP.EVEN_DB_BUF.n12 XCAP.EVEN_DB_BUF.n11 21.1228
R6701 XCAP.EVEN_DB_BUF.n11 XCAP.EVEN_DB_BUF.n10 18.4942
R6702 XCAP.EVEN_DB_BUF.n9 XCAP.EVEN_DB_BUF.n6 18.4942
R6703 XCAP.EVEN_DB_BUF.n3 XCAP.EVEN_DB_BUF.n0 18.4942
R6704 XCAP.EVEN_DB_BUF.n5 XCAP.EVEN_DB_BUF.n4 18.4942
R6705 XCAP.EVEN_DB_BUF.n10 XCAP.EVEN_DB_BUF.n9 11.6805
R6706 XCAP.EVEN_DB_BUF.n9 XCAP.EVEN_DB_BUF.n8 11.6805
R6707 XCAP.EVEN_DB_BUF.n3 XCAP.EVEN_DB_BUF.n2 11.6805
R6708 XCAP.EVEN_DB_BUF.n4 XCAP.EVEN_DB_BUF.n3 11.6805
R6709 XCAP.EVEN_DB_BUF.n23 XCAP.EVEN_DB_BUF.n15 10.3701
R6710 XCAP.EVEN_DB_BUF.n12 XCAP.EVEN_DB_BUF.n5 10.3228
R6711 XCAP.EVEN_DB_BUF.n7 XCAP.EVEN_DB_BUF.n6 7.17687
R6712 XCAP.EVEN_DB_BUF.n1 XCAP.EVEN_DB_BUF.n0 7.17687
R6713 XCAP.EVEN_DB_BUF.n24 XCAP.EVEN_DB_BUF.n12 6.53528
R6714 XCAP.EVEN_DB_BUF.n14 XCAP.EVEN_DB_BUF.t11 5.7796
R6715 XCAP.EVEN_DB_BUF.n17 XCAP.EVEN_DB_BUF.t7 5.73764
R6716 XCAP.EVEN_DB_BUF.n21 XCAP.EVEN_DB_BUF.t0 5.73764
R6717 XCAP.EVEN_DB_BUF.n15 XCAP.EVEN_DB_BUF.t8 5.68486
R6718 XCAP.EVEN_DB_BUF.n14 XCAP.EVEN_DB_BUF.n13 5.38537
R6719 XCAP.EVEN_DB_BUF.n17 XCAP.EVEN_DB_BUF.n16 5.32067
R6720 XCAP.EVEN_DB_BUF.n19 XCAP.EVEN_DB_BUF.n18 5.32067
R6721 XCAP.EVEN_DB_BUF.n21 XCAP.EVEN_DB_BUF.n20 5.32067
R6722 XCAP.EVEN_DB_BUF.n24 XCAP.EVEN_DB_BUF.n23 4.73528
R6723 XCAP.EVEN_DB_BUF.n23 XCAP.EVEN_DB_BUF.n22 4.5005
R6724 XCAP.EVEN_DB_BUF.n8 XCAP.EVEN_DB_BUF.n7 4.42851
R6725 XCAP.EVEN_DB_BUF.n2 XCAP.EVEN_DB_BUF.n1 4.42851
R6726 XCAP.EVEN_DB_BUF.n16 XCAP.EVEN_DB_BUF.t5 0.228
R6727 XCAP.EVEN_DB_BUF.n16 XCAP.EVEN_DB_BUF.t6 0.228
R6728 XCAP.EVEN_DB_BUF.n18 XCAP.EVEN_DB_BUF.t3 0.228
R6729 XCAP.EVEN_DB_BUF.n18 XCAP.EVEN_DB_BUF.t4 0.228
R6730 XCAP.EVEN_DB_BUF.n20 XCAP.EVEN_DB_BUF.t1 0.228
R6731 XCAP.EVEN_DB_BUF.n20 XCAP.EVEN_DB_BUF.t2 0.228
R6732 XCAP.EVEN_DB_BUF.n13 XCAP.EVEN_DB_BUF.t9 0.20525
R6733 XCAP.EVEN_DB_BUF.n13 XCAP.EVEN_DB_BUF.t10 0.20525
R6734 XCAP.EVEN_DB_BUF.n19 XCAP.EVEN_DB_BUF.n17 0.189974
R6735 XCAP.EVEN_DB_BUF.n11 XCAP.EVEN_DB_BUF.n6 0.1205
R6736 XCAP.EVEN_DB_BUF.n5 XCAP.EVEN_DB_BUF.n0 0.1205
R6737 XCAP.EVEN_DB_BUF.n22 XCAP.EVEN_DB_BUF.n21 0.0952368
R6738 XCAP.EVEN_DB_BUF.n22 XCAP.EVEN_DB_BUF.n19 0.0952368
R6739 XCAP.EVEN_DB_BUF.n15 XCAP.EVEN_DB_BUF.n14 0.0952368
R6740 XCAP.EVEN_DB_BUF XCAP.EVEN_DB_BUF.n24 0.0396304
R6741 XCAP.E_QI.n15 XCAP.E_QI.t19 113.632
R6742 XCAP.E_QI.n1 XCAP.E_QI.t12 113.618
R6743 XCAP.E_QI.n1 XCAP.E_QI.t13 113.618
R6744 XCAP.E_QI.n0 XCAP.E_QI.t16 113.618
R6745 XCAP.E_QI.n0 XCAP.E_QI.t17 113.618
R6746 XCAP.E_QI.n15 XCAP.E_QI.t18 113.603
R6747 XCAP.E_QI.n16 XCAP.E_QI.t15 61.4885
R6748 XCAP.E_QI.n16 XCAP.E_QI.t14 61.4598
R6749 XCAP.E_QI.n17 XCAP.E_QI.n15 21.3118
R6750 XCAP.E_QI.n2 XCAP.E_QI.n0 20.0331
R6751 XCAP.E_QI.n2 XCAP.E_QI.n1 16.9809
R6752 XCAP.E_QI.n17 XCAP.E_QI.n16 16.2249
R6753 XCAP.E_QI.n13 XCAP.E_QI.n12 9.15702
R6754 XCAP.E_QI.n7 XCAP.E_QI.n5 7.43528
R6755 XCAP.E_QI.n14 XCAP.E_QI.n2 7.00485
R6756 XCAP.E_QI.n18 XCAP.E_QI.n17 6.32007
R6757 XCAP.E_QI.n11 XCAP.E_QI.t3 5.7796
R6758 XCAP.E_QI.n8 XCAP.E_QI.t9 5.7796
R6759 XCAP.E_QI.n4 XCAP.E_QI.t7 5.73764
R6760 XCAP.E_QI.n6 XCAP.E_QI.t10 5.73764
R6761 XCAP.E_QI.n12 XCAP.E_QI.t0 5.68486
R6762 XCAP.E_QI.n5 XCAP.E_QI.t4 5.6429
R6763 XCAP.E_QI.n8 XCAP.E_QI.t11 5.59012
R6764 XCAP.E_QI.n6 XCAP.E_QI.t8 5.54817
R6765 XCAP.E_QI.n11 XCAP.E_QI.n10 5.38537
R6766 XCAP.E_QI.n4 XCAP.E_QI.n3 5.32067
R6767 XCAP.E_QI.n9 XCAP.E_QI.n7 4.8918
R6768 XCAP.E_QI.n7 XCAP.E_QI.n6 4.5005
R6769 XCAP.E_QI.n9 XCAP.E_QI.n8 4.5005
R6770 XCAP.E_QI.n14 XCAP.E_QI.n13 4.5005
R6771 XCAP.E_QI.n18 XCAP.E_QI.n14 4.22659
R6772 XCAP.E_QI.n13 XCAP.E_QI.n9 0.626587
R6773 XCAP.E_QI.n3 XCAP.E_QI.t5 0.228
R6774 XCAP.E_QI.n3 XCAP.E_QI.t6 0.228
R6775 XCAP.E_QI.n10 XCAP.E_QI.t1 0.20525
R6776 XCAP.E_QI.n10 XCAP.E_QI.t2 0.20525
R6777 XCAP.E_QI.n12 XCAP.E_QI.n11 0.0952368
R6778 XCAP.E_QI.n5 XCAP.E_QI.n4 0.0952368
R6779 XCAP.E_QI XCAP.E_QI.n18 0.0396304
R6780 XCAP.O_QBBUF.n0 XCAP.O_QBBUF.t7 113.632
R6781 XCAP.O_QBBUF.n3 XCAP.O_QBBUF.t10 113.632
R6782 XCAP.O_QBBUF.n7 XCAP.O_QBBUF.t6 113.629
R6783 XCAP.O_QBBUF.n5 XCAP.O_QBBUF.t4 109.174
R6784 XCAP.O_QBBUF.n6 XCAP.O_QBBUF.t5 109.174
R6785 XCAP.O_QBBUF.n1 XCAP.O_QBBUF.t8 109.174
R6786 XCAP.O_QBBUF.n2 XCAP.O_QBBUF.t9 109.174
R6787 XCAP.O_QBBUF.n8 XCAP.O_QBBUF.n5 18.6022
R6788 XCAP.O_QBBUF.n9 XCAP.O_QBBUF.n4 17.394
R6789 XCAP.O_QBBUF.n6 XCAP.O_QBBUF.n5 11.6805
R6790 XCAP.O_QBBUF.n2 XCAP.O_QBBUF.n1 11.6805
R6791 XCAP.O_QBBUF.n12 XCAP.O_QBBUF.n10 10.4648
R6792 XCAP.O_QBBUF.n9 XCAP.O_QBBUF.n8 9.21572
R6793 XCAP.O_QBBUF.n13 XCAP.O_QBBUF.n9 7.16137
R6794 XCAP.O_QBBUF.n4 XCAP.O_QBBUF.n0 7.10487
R6795 XCAP.O_QBBUF.n4 XCAP.O_QBBUF.n3 7.10487
R6796 XCAP.O_QBBUF.n8 XCAP.O_QBBUF.n7 7.05405
R6797 XCAP.O_QBBUF.n11 XCAP.O_QBBUF.t3 6.07983
R6798 XCAP.O_QBBUF.n11 XCAP.O_QBBUF.t2 5.89036
R6799 XCAP.O_QBBUF.n10 XCAP.O_QBBUF.t1 5.73764
R6800 XCAP.O_QBBUF.n10 XCAP.O_QBBUF.t0 5.54817
R6801 XCAP.O_QBBUF.n13 XCAP.O_QBBUF.n12 5.43963
R6802 XCAP.O_QBBUF.n12 XCAP.O_QBBUF.n11 4.59524
R6803 XCAP.O_QBBUF.n7 XCAP.O_QBBUF.n6 4.4296
R6804 XCAP.O_QBBUF.n1 XCAP.O_QBBUF.n0 4.42851
R6805 XCAP.O_QBBUF.n3 XCAP.O_QBBUF.n2 4.42851
R6806 XCAP.O_QBBUF XCAP.O_QBBUF.n13 0.0396304
R6807 XCAP.O_QBUF.n0 XCAP.O_QBUF.t7 113.632
R6808 XCAP.O_QBUF.n3 XCAP.O_QBUF.t10 113.632
R6809 XCAP.O_QBUF.n7 XCAP.O_QBUF.t6 113.629
R6810 XCAP.O_QBUF.n5 XCAP.O_QBUF.t4 109.174
R6811 XCAP.O_QBUF.n6 XCAP.O_QBUF.t5 109.174
R6812 XCAP.O_QBUF.n1 XCAP.O_QBUF.t8 109.174
R6813 XCAP.O_QBUF.n2 XCAP.O_QBUF.t9 109.174
R6814 XCAP.O_QBUF.n8 XCAP.O_QBUF.n5 18.6022
R6815 XCAP.O_QBUF.n9 XCAP.O_QBUF.n4 17.1201
R6816 XCAP.O_QBUF.n6 XCAP.O_QBUF.n5 11.6805
R6817 XCAP.O_QBUF.n2 XCAP.O_QBUF.n1 11.6805
R6818 XCAP.O_QBUF.n12 XCAP.O_QBUF.n10 10.4648
R6819 XCAP.O_QBUF.n9 XCAP.O_QBUF.n8 9.48963
R6820 XCAP.O_QBUF.n13 XCAP.O_QBUF.n9 7.16137
R6821 XCAP.O_QBUF.n4 XCAP.O_QBUF.n0 7.10487
R6822 XCAP.O_QBUF.n4 XCAP.O_QBUF.n3 7.10487
R6823 XCAP.O_QBUF.n8 XCAP.O_QBUF.n7 7.05405
R6824 XCAP.O_QBUF.n11 XCAP.O_QBUF.t0 6.07983
R6825 XCAP.O_QBUF.n11 XCAP.O_QBUF.t1 5.89036
R6826 XCAP.O_QBUF.n10 XCAP.O_QBUF.t2 5.73764
R6827 XCAP.O_QBUF.n10 XCAP.O_QBUF.t3 5.54817
R6828 XCAP.O_QBUF.n13 XCAP.O_QBUF.n12 5.16572
R6829 XCAP.O_QBUF.n12 XCAP.O_QBUF.n11 4.59524
R6830 XCAP.O_QBUF.n7 XCAP.O_QBUF.n6 4.4296
R6831 XCAP.O_QBUF.n1 XCAP.O_QBUF.n0 4.42851
R6832 XCAP.O_QBUF.n3 XCAP.O_QBUF.n2 4.42851
R6833 XCAP.O_QBUF XCAP.O_QBUF.n13 0.0396304
R6834 XCAP.E_QBUF.n3 XCAP.E_QBUF.t7 113.632
R6835 XCAP.E_QBUF.n6 XCAP.E_QBUF.t10 113.632
R6836 XCAP.E_QBUF.n10 XCAP.E_QBUF.t6 113.629
R6837 XCAP.E_QBUF.n8 XCAP.E_QBUF.t4 109.174
R6838 XCAP.E_QBUF.n9 XCAP.E_QBUF.t5 109.174
R6839 XCAP.E_QBUF.n4 XCAP.E_QBUF.t8 109.174
R6840 XCAP.E_QBUF.n5 XCAP.E_QBUF.t9 109.174
R6841 XCAP.E_QBUF.n11 XCAP.E_QBUF.n8 18.6022
R6842 XCAP.E_QBUF.n12 XCAP.E_QBUF.n7 17.6092
R6843 XCAP.E_QBUF.n9 XCAP.E_QBUF.n8 11.6805
R6844 XCAP.E_QBUF.n5 XCAP.E_QBUF.n4 11.6805
R6845 XCAP.E_QBUF.n2 XCAP.E_QBUF.n0 10.4648
R6846 XCAP.E_QBUF.n12 XCAP.E_QBUF.n11 9.0005
R6847 XCAP.E_QBUF.n13 XCAP.E_QBUF.n2 7.74833
R6848 XCAP.E_QBUF.n7 XCAP.E_QBUF.n3 7.10487
R6849 XCAP.E_QBUF.n7 XCAP.E_QBUF.n6 7.10487
R6850 XCAP.E_QBUF.n11 XCAP.E_QBUF.n10 7.05405
R6851 XCAP.E_QBUF.n1 XCAP.E_QBUF.t3 6.07983
R6852 XCAP.E_QBUF.n1 XCAP.E_QBUF.t2 5.89036
R6853 XCAP.E_QBUF.n0 XCAP.E_QBUF.t1 5.73764
R6854 XCAP.E_QBUF.n0 XCAP.E_QBUF.t0 5.54817
R6855 XCAP.E_QBUF.n2 XCAP.E_QBUF.n1 4.59524
R6856 XCAP.E_QBUF.n13 XCAP.E_QBUF.n12 4.5592
R6857 XCAP.E_QBUF.n10 XCAP.E_QBUF.n9 4.4296
R6858 XCAP.E_QBUF.n4 XCAP.E_QBUF.n3 4.42851
R6859 XCAP.E_QBUF.n6 XCAP.E_QBUF.n5 4.42851
R6860 XCAP.E_QBUF XCAP.E_QBUF.n13 0.0396304
R6861 XCAP.E_QBBUF.n3 XCAP.E_QBBUF.t7 113.632
R6862 XCAP.E_QBBUF.n6 XCAP.E_QBBUF.t10 113.632
R6863 XCAP.E_QBBUF.n10 XCAP.E_QBBUF.t6 113.629
R6864 XCAP.E_QBBUF.n8 XCAP.E_QBBUF.t4 109.174
R6865 XCAP.E_QBBUF.n9 XCAP.E_QBBUF.t5 109.174
R6866 XCAP.E_QBBUF.n4 XCAP.E_QBBUF.t8 109.174
R6867 XCAP.E_QBBUF.n5 XCAP.E_QBBUF.t9 109.174
R6868 XCAP.E_QBBUF.n11 XCAP.E_QBBUF.n8 18.6022
R6869 XCAP.E_QBBUF.n12 XCAP.E_QBBUF.n7 17.6092
R6870 XCAP.E_QBBUF.n9 XCAP.E_QBBUF.n8 11.6805
R6871 XCAP.E_QBBUF.n5 XCAP.E_QBBUF.n4 11.6805
R6872 XCAP.E_QBBUF.n2 XCAP.E_QBBUF.n0 10.4648
R6873 XCAP.E_QBBUF.n12 XCAP.E_QBBUF.n11 9.0005
R6874 XCAP.E_QBBUF.n13 XCAP.E_QBBUF.n2 8.02224
R6875 XCAP.E_QBBUF.n7 XCAP.E_QBBUF.n3 7.10487
R6876 XCAP.E_QBBUF.n7 XCAP.E_QBBUF.n6 7.10487
R6877 XCAP.E_QBBUF.n11 XCAP.E_QBBUF.n10 7.05405
R6878 XCAP.E_QBBUF.n1 XCAP.E_QBBUF.t3 6.07983
R6879 XCAP.E_QBBUF.n1 XCAP.E_QBBUF.t2 5.89036
R6880 XCAP.E_QBBUF.n0 XCAP.E_QBBUF.t1 5.73764
R6881 XCAP.E_QBBUF.n0 XCAP.E_QBBUF.t0 5.54817
R6882 XCAP.E_QBBUF.n13 XCAP.E_QBBUF.n12 4.83311
R6883 XCAP.E_QBBUF.n2 XCAP.E_QBBUF.n1 4.59524
R6884 XCAP.E_QBBUF.n10 XCAP.E_QBBUF.n9 4.4296
R6885 XCAP.E_QBBUF.n4 XCAP.E_QBBUF.n3 4.42851
R6886 XCAP.E_QBBUF.n6 XCAP.E_QBBUF.n5 4.42851
R6887 XCAP.E_QBBUF XCAP.E_QBBUF.n13 0.0396304
R6888 XCAP.O_QBI.n14 XCAP.O_QBI.t19 113.632
R6889 XCAP.O_QBI.n4 XCAP.O_QBI.t12 113.618
R6890 XCAP.O_QBI.n4 XCAP.O_QBI.t13 113.618
R6891 XCAP.O_QBI.n2 XCAP.O_QBI.t16 113.618
R6892 XCAP.O_QBI.n2 XCAP.O_QBI.t17 113.618
R6893 XCAP.O_QBI.n14 XCAP.O_QBI.t18 113.603
R6894 XCAP.O_QBI.n15 XCAP.O_QBI.t15 61.4885
R6895 XCAP.O_QBI.n15 XCAP.O_QBI.t14 61.4598
R6896 XCAP.O_QBI.n16 XCAP.O_QBI.n14 21.4318
R6897 XCAP.O_QBI.n5 XCAP.O_QBI.n4 17.8026
R6898 XCAP.O_QBI.n16 XCAP.O_QBI.n15 16.3449
R6899 XCAP.O_QBI.n3 XCAP.O_QBI.n2 16.0613
R6900 XCAP.O_QBI.n3 XCAP.O_QBI.n1 14.0679
R6901 XCAP.O_QBI.n12 XCAP.O_QBI.n6 9.19615
R6902 XCAP.O_QBI.n11 XCAP.O_QBI.n9 7.43528
R6903 XCAP.O_QBI.n13 XCAP.O_QBI.n5 7.00485
R6904 XCAP.O_QBI.n8 XCAP.O_QBI.t0 5.7796
R6905 XCAP.O_QBI.n10 XCAP.O_QBI.t4 5.7796
R6906 XCAP.O_QBI.n6 XCAP.O_QBI.t2 5.73764
R6907 XCAP.O_QBI.n1 XCAP.O_QBI.t6 5.73764
R6908 XCAP.O_QBI.n1 XCAP.O_QBI.t7 5.73764
R6909 XCAP.O_QBI.n9 XCAP.O_QBI.t5 5.68486
R6910 XCAP.O_QBI.n10 XCAP.O_QBI.t3 5.59012
R6911 XCAP.O_QBI.n6 XCAP.O_QBI.t1 5.54817
R6912 XCAP.O_QBI.n17 XCAP.O_QBI.n16 5.49833
R6913 XCAP.O_QBI.n8 XCAP.O_QBI.n7 5.38537
R6914 XCAP.O_QBI.n1 XCAP.O_QBI.n0 5.32067
R6915 XCAP.O_QBI.n11 XCAP.O_QBI.n10 4.5005
R6916 XCAP.O_QBI.n13 XCAP.O_QBI.n12 4.5005
R6917 XCAP.O_QBI.n5 XCAP.O_QBI.n3 3.1505
R6918 XCAP.O_QBI.n17 XCAP.O_QBI.n13 2.89615
R6919 XCAP.O_QBI.n0 XCAP.O_QBI.t11 0.228
R6920 XCAP.O_QBI.n0 XCAP.O_QBI.t10 0.228
R6921 XCAP.O_QBI.n7 XCAP.O_QBI.t9 0.20525
R6922 XCAP.O_QBI.n7 XCAP.O_QBI.t8 0.20525
R6923 XCAP.O_QBI.n12 XCAP.O_QBI.n11 0.196152
R6924 XCAP.O_QBI.n9 XCAP.O_QBI.n8 0.0952368
R6925 XCAP.O_QBI XCAP.O_QBI.n17 0.0396304
R6926 XCAP.O_PRST_TAIL.n10 XCAP.O_PRST_TAIL.n2 19.1064
R6927 XCAP.O_PRST_TAIL.n10 XCAP.O_PRST_TAIL.n9 17.603
R6928 XCAP.O_PRST_TAIL.n4 XCAP.O_PRST_TAIL.t11 5.73764
R6929 XCAP.O_PRST_TAIL.n9 XCAP.O_PRST_TAIL.t4 5.54817
R6930 XCAP.O_PRST_TAIL.n2 XCAP.O_PRST_TAIL.n0 5.51014
R6931 XCAP.O_PRST_TAIL.n4 XCAP.O_PRST_TAIL.n3 5.32067
R6932 XCAP.O_PRST_TAIL.n2 XCAP.O_PRST_TAIL.n1 5.32067
R6933 XCAP.O_PRST_TAIL.n6 XCAP.O_PRST_TAIL.n5 5.32067
R6934 XCAP.O_PRST_TAIL.n8 XCAP.O_PRST_TAIL.n7 5.32067
R6935 XCAP.O_PRST_TAIL.n3 XCAP.O_PRST_TAIL.t9 0.228
R6936 XCAP.O_PRST_TAIL.n3 XCAP.O_PRST_TAIL.t10 0.228
R6937 XCAP.O_PRST_TAIL.n0 XCAP.O_PRST_TAIL.t2 0.228
R6938 XCAP.O_PRST_TAIL.n0 XCAP.O_PRST_TAIL.t0 0.228
R6939 XCAP.O_PRST_TAIL.n1 XCAP.O_PRST_TAIL.t1 0.228
R6940 XCAP.O_PRST_TAIL.n1 XCAP.O_PRST_TAIL.t3 0.228
R6941 XCAP.O_PRST_TAIL.n5 XCAP.O_PRST_TAIL.t7 0.228
R6942 XCAP.O_PRST_TAIL.n5 XCAP.O_PRST_TAIL.t8 0.228
R6943 XCAP.O_PRST_TAIL.n7 XCAP.O_PRST_TAIL.t5 0.228
R6944 XCAP.O_PRST_TAIL.n7 XCAP.O_PRST_TAIL.t6 0.228
R6945 XCAP.O_PRST_TAIL.n9 XCAP.O_PRST_TAIL.n8 0.189974
R6946 XCAP.O_PRST_TAIL.n8 XCAP.O_PRST_TAIL.n6 0.189974
R6947 XCAP.O_PRST_TAIL.n6 XCAP.O_PRST_TAIL.n4 0.189974
R6948 XCAP.O_PRST_TAIL XCAP.O_PRST_TAIL.n10 0.0396304
R6949 XCAP.E_PRST_TAIL.n10 XCAP.E_PRST_TAIL.n6 24.2305
R6950 XCAP.E_PRST_TAIL.n10 XCAP.E_PRST_TAIL.n9 17.0881
R6951 XCAP.E_PRST_TAIL.n1 XCAP.E_PRST_TAIL.t4 5.73764
R6952 XCAP.E_PRST_TAIL.n6 XCAP.E_PRST_TAIL.t11 5.54817
R6953 XCAP.E_PRST_TAIL.n9 XCAP.E_PRST_TAIL.n7 5.51014
R6954 XCAP.E_PRST_TAIL.n5 XCAP.E_PRST_TAIL.n4 5.32067
R6955 XCAP.E_PRST_TAIL.n9 XCAP.E_PRST_TAIL.n8 5.32067
R6956 XCAP.E_PRST_TAIL.n3 XCAP.E_PRST_TAIL.n2 5.32067
R6957 XCAP.E_PRST_TAIL.n1 XCAP.E_PRST_TAIL.n0 5.32067
R6958 XCAP.E_PRST_TAIL.n4 XCAP.E_PRST_TAIL.t9 0.228
R6959 XCAP.E_PRST_TAIL.n4 XCAP.E_PRST_TAIL.t10 0.228
R6960 XCAP.E_PRST_TAIL.n7 XCAP.E_PRST_TAIL.t3 0.228
R6961 XCAP.E_PRST_TAIL.n7 XCAP.E_PRST_TAIL.t2 0.228
R6962 XCAP.E_PRST_TAIL.n8 XCAP.E_PRST_TAIL.t1 0.228
R6963 XCAP.E_PRST_TAIL.n8 XCAP.E_PRST_TAIL.t0 0.228
R6964 XCAP.E_PRST_TAIL.n2 XCAP.E_PRST_TAIL.t7 0.228
R6965 XCAP.E_PRST_TAIL.n2 XCAP.E_PRST_TAIL.t8 0.228
R6966 XCAP.E_PRST_TAIL.n0 XCAP.E_PRST_TAIL.t5 0.228
R6967 XCAP.E_PRST_TAIL.n0 XCAP.E_PRST_TAIL.t6 0.228
R6968 XCAP.E_PRST_TAIL.n3 XCAP.E_PRST_TAIL.n1 0.189974
R6969 XCAP.E_PRST_TAIL.n5 XCAP.E_PRST_TAIL.n3 0.189974
R6970 XCAP.E_PRST_TAIL.n6 XCAP.E_PRST_TAIL.n5 0.189974
R6971 XCAP.E_PRST_TAIL XCAP.E_PRST_TAIL.n10 0.0396304
R6972 XCAP.E_QBI.n0 XCAP.E_QBI.t19 113.632
R6973 XCAP.E_QBI.n15 XCAP.E_QBI.t12 113.618
R6974 XCAP.E_QBI.n15 XCAP.E_QBI.t13 113.618
R6975 XCAP.E_QBI.n13 XCAP.E_QBI.t16 113.618
R6976 XCAP.E_QBI.n13 XCAP.E_QBI.t17 113.618
R6977 XCAP.E_QBI.n0 XCAP.E_QBI.t18 113.603
R6978 XCAP.E_QBI.n1 XCAP.E_QBI.t15 61.4885
R6979 XCAP.E_QBI.n1 XCAP.E_QBI.t14 61.4598
R6980 XCAP.E_QBI.n2 XCAP.E_QBI.n0 21.4318
R6981 XCAP.E_QBI.n16 XCAP.E_QBI.n15 17.2548
R6982 XCAP.E_QBI.n2 XCAP.E_QBI.n1 16.3449
R6983 XCAP.E_QBI.n14 XCAP.E_QBI.n13 16.0613
R6984 XCAP.E_QBI.n14 XCAP.E_QBI.n12 14.0679
R6985 XCAP.E_QBI.n10 XCAP.E_QBI.n2 10.194
R6986 XCAP.E_QBI.n5 XCAP.E_QBI.n3 9.3918
R6987 XCAP.E_QBI.n9 XCAP.E_QBI.n8 7.08311
R6988 XCAP.E_QBI.n7 XCAP.E_QBI.t0 5.7796
R6989 XCAP.E_QBI.n4 XCAP.E_QBI.t7 5.7796
R6990 XCAP.E_QBI.n3 XCAP.E_QBI.t5 5.73764
R6991 XCAP.E_QBI.n12 XCAP.E_QBI.t10 5.73764
R6992 XCAP.E_QBI.n12 XCAP.E_QBI.t3 5.73764
R6993 XCAP.E_QBI.n8 XCAP.E_QBI.t9 5.68486
R6994 XCAP.E_QBI.n4 XCAP.E_QBI.t6 5.59012
R6995 XCAP.E_QBI.n3 XCAP.E_QBI.t4 5.54817
R6996 XCAP.E_QBI.n7 XCAP.E_QBI.n6 5.38537
R6997 XCAP.E_QBI.n12 XCAP.E_QBI.n11 5.32067
R6998 XCAP.E_QBI.n5 XCAP.E_QBI.n4 4.5005
R6999 XCAP.E_QBI.n10 XCAP.E_QBI.n9 4.5005
R7000 XCAP.E_QBI.n17 XCAP.E_QBI.n16 4.5005
R7001 XCAP.E_QBI.n16 XCAP.E_QBI.n14 3.69833
R7002 XCAP.E_QBI.n17 XCAP.E_QBI.n10 2.1918
R7003 XCAP.E_QBI.n9 XCAP.E_QBI.n5 0.352674
R7004 XCAP.E_QBI.n11 XCAP.E_QBI.t2 0.228
R7005 XCAP.E_QBI.n11 XCAP.E_QBI.t11 0.228
R7006 XCAP.E_QBI.n6 XCAP.E_QBI.t8 0.20525
R7007 XCAP.E_QBI.n6 XCAP.E_QBI.t1 0.20525
R7008 XCAP.E_QBI.n8 XCAP.E_QBI.n7 0.0952368
R7009 XCAP.E_QBI XCAP.E_QBI.n17 0.0396304
R7010 XCAP.ODD_D_BUF.n19 XCAP.ODD_D_BUF.t12 113.632
R7011 XCAP.ODD_D_BUF.n12 XCAP.ODD_D_BUF.t19 113.632
R7012 XCAP.ODD_D_BUF.n22 XCAP.ODD_D_BUF.t15 109.174
R7013 XCAP.ODD_D_BUF.n21 XCAP.ODD_D_BUF.t14 109.174
R7014 XCAP.ODD_D_BUF.n20 XCAP.ODD_D_BUF.t13 109.174
R7015 XCAP.ODD_D_BUF.n15 XCAP.ODD_D_BUF.t16 109.174
R7016 XCAP.ODD_D_BUF.n14 XCAP.ODD_D_BUF.t17 109.174
R7017 XCAP.ODD_D_BUF.n13 XCAP.ODD_D_BUF.t18 109.174
R7018 XCAP.ODD_D_BUF.n24 XCAP.ODD_D_BUF.n23 23.4289
R7019 XCAP.ODD_D_BUF.n17 XCAP.ODD_D_BUF.n16 20.1159
R7020 XCAP.ODD_D_BUF.n23 XCAP.ODD_D_BUF.n22 18.4942
R7021 XCAP.ODD_D_BUF.n21 XCAP.ODD_D_BUF.n18 18.4942
R7022 XCAP.ODD_D_BUF.n16 XCAP.ODD_D_BUF.n15 18.4942
R7023 XCAP.ODD_D_BUF.n14 XCAP.ODD_D_BUF.n11 18.4942
R7024 XCAP.ODD_D_BUF.n22 XCAP.ODD_D_BUF.n21 11.6805
R7025 XCAP.ODD_D_BUF.n21 XCAP.ODD_D_BUF.n20 11.6805
R7026 XCAP.ODD_D_BUF.n15 XCAP.ODD_D_BUF.n14 11.6805
R7027 XCAP.ODD_D_BUF.n14 XCAP.ODD_D_BUF.n13 11.6805
R7028 XCAP.ODD_D_BUF.n10 XCAP.ODD_D_BUF.n2 10.3701
R7029 XCAP.ODD_D_BUF.n17 XCAP.ODD_D_BUF.n10 8.45267
R7030 XCAP.ODD_D_BUF.n19 XCAP.ODD_D_BUF.n18 7.17687
R7031 XCAP.ODD_D_BUF.n12 XCAP.ODD_D_BUF.n11 7.17687
R7032 XCAP.ODD_D_BUF.n1 XCAP.ODD_D_BUF.t11 5.7796
R7033 XCAP.ODD_D_BUF.n4 XCAP.ODD_D_BUF.t7 5.73764
R7034 XCAP.ODD_D_BUF.n8 XCAP.ODD_D_BUF.t0 5.73764
R7035 XCAP.ODD_D_BUF.n2 XCAP.ODD_D_BUF.t8 5.68486
R7036 XCAP.ODD_D_BUF.n1 XCAP.ODD_D_BUF.n0 5.38537
R7037 XCAP.ODD_D_BUF.n4 XCAP.ODD_D_BUF.n3 5.32067
R7038 XCAP.ODD_D_BUF.n6 XCAP.ODD_D_BUF.n5 5.32067
R7039 XCAP.ODD_D_BUF.n8 XCAP.ODD_D_BUF.n7 5.32067
R7040 XCAP.ODD_D_BUF.n10 XCAP.ODD_D_BUF.n9 4.5005
R7041 XCAP.ODD_D_BUF.n20 XCAP.ODD_D_BUF.n19 4.42851
R7042 XCAP.ODD_D_BUF.n13 XCAP.ODD_D_BUF.n12 4.42851
R7043 XCAP.ODD_D_BUF.n24 XCAP.ODD_D_BUF.n17 3.75702
R7044 XCAP.ODD_D_BUF.n3 XCAP.ODD_D_BUF.t5 0.228
R7045 XCAP.ODD_D_BUF.n3 XCAP.ODD_D_BUF.t6 0.228
R7046 XCAP.ODD_D_BUF.n5 XCAP.ODD_D_BUF.t3 0.228
R7047 XCAP.ODD_D_BUF.n5 XCAP.ODD_D_BUF.t4 0.228
R7048 XCAP.ODD_D_BUF.n7 XCAP.ODD_D_BUF.t1 0.228
R7049 XCAP.ODD_D_BUF.n7 XCAP.ODD_D_BUF.t2 0.228
R7050 XCAP.ODD_D_BUF.n0 XCAP.ODD_D_BUF.t9 0.20525
R7051 XCAP.ODD_D_BUF.n0 XCAP.ODD_D_BUF.t10 0.20525
R7052 XCAP.ODD_D_BUF.n6 XCAP.ODD_D_BUF.n4 0.189974
R7053 XCAP.ODD_D_BUF.n23 XCAP.ODD_D_BUF.n18 0.1205
R7054 XCAP.ODD_D_BUF.n16 XCAP.ODD_D_BUF.n11 0.1205
R7055 XCAP.ODD_D_BUF.n9 XCAP.ODD_D_BUF.n8 0.0952368
R7056 XCAP.ODD_D_BUF.n9 XCAP.ODD_D_BUF.n6 0.0952368
R7057 XCAP.ODD_D_BUF.n2 XCAP.ODD_D_BUF.n1 0.0952368
R7058 XCAP.ODD_D_BUF XCAP.ODD_D_BUF.n24 0.0396304
R7059 XCAP.EVEN_D_BUF.n1 XCAP.EVEN_D_BUF.t12 113.632
R7060 XCAP.EVEN_D_BUF.n7 XCAP.EVEN_D_BUF.t16 113.632
R7061 XCAP.EVEN_D_BUF.n4 XCAP.EVEN_D_BUF.t15 109.174
R7062 XCAP.EVEN_D_BUF.n3 XCAP.EVEN_D_BUF.t14 109.174
R7063 XCAP.EVEN_D_BUF.n2 XCAP.EVEN_D_BUF.t13 109.174
R7064 XCAP.EVEN_D_BUF.n8 XCAP.EVEN_D_BUF.t17 109.174
R7065 XCAP.EVEN_D_BUF.n9 XCAP.EVEN_D_BUF.t18 109.174
R7066 XCAP.EVEN_D_BUF.n10 XCAP.EVEN_D_BUF.t19 109.174
R7067 XCAP.EVEN_D_BUF.n12 XCAP.EVEN_D_BUF.n5 25.855
R7068 XCAP.EVEN_D_BUF.n12 XCAP.EVEN_D_BUF.n11 20.5437
R7069 XCAP.EVEN_D_BUF.n5 XCAP.EVEN_D_BUF.n4 18.4942
R7070 XCAP.EVEN_D_BUF.n3 XCAP.EVEN_D_BUF.n0 18.4942
R7071 XCAP.EVEN_D_BUF.n9 XCAP.EVEN_D_BUF.n6 18.4942
R7072 XCAP.EVEN_D_BUF.n11 XCAP.EVEN_D_BUF.n10 18.4942
R7073 XCAP.EVEN_D_BUF.n4 XCAP.EVEN_D_BUF.n3 11.6805
R7074 XCAP.EVEN_D_BUF.n3 XCAP.EVEN_D_BUF.n2 11.6805
R7075 XCAP.EVEN_D_BUF.n9 XCAP.EVEN_D_BUF.n8 11.6805
R7076 XCAP.EVEN_D_BUF.n10 XCAP.EVEN_D_BUF.n9 11.6805
R7077 XCAP.EVEN_D_BUF.n23 XCAP.EVEN_D_BUF.n22 10.3309
R7078 XCAP.EVEN_D_BUF.n1 XCAP.EVEN_D_BUF.n0 7.17687
R7079 XCAP.EVEN_D_BUF.n7 XCAP.EVEN_D_BUF.n6 7.17687
R7080 XCAP.EVEN_D_BUF.n21 XCAP.EVEN_D_BUF.t11 5.7796
R7081 XCAP.EVEN_D_BUF.n14 XCAP.EVEN_D_BUF.t7 5.73764
R7082 XCAP.EVEN_D_BUF.n18 XCAP.EVEN_D_BUF.t0 5.73764
R7083 XCAP.EVEN_D_BUF.n22 XCAP.EVEN_D_BUF.t8 5.68486
R7084 XCAP.EVEN_D_BUF.n21 XCAP.EVEN_D_BUF.n20 5.38537
R7085 XCAP.EVEN_D_BUF.n14 XCAP.EVEN_D_BUF.n13 5.32067
R7086 XCAP.EVEN_D_BUF.n16 XCAP.EVEN_D_BUF.n15 5.32067
R7087 XCAP.EVEN_D_BUF.n18 XCAP.EVEN_D_BUF.n17 5.32067
R7088 XCAP.EVEN_D_BUF.n23 XCAP.EVEN_D_BUF.n19 4.53963
R7089 XCAP.EVEN_D_BUF.n24 XCAP.EVEN_D_BUF.n23 4.5005
R7090 XCAP.EVEN_D_BUF.n2 XCAP.EVEN_D_BUF.n1 4.42851
R7091 XCAP.EVEN_D_BUF.n8 XCAP.EVEN_D_BUF.n7 4.42851
R7092 XCAP.EVEN_D_BUF.n24 XCAP.EVEN_D_BUF.n12 3.91354
R7093 XCAP.EVEN_D_BUF.n13 XCAP.EVEN_D_BUF.t5 0.228
R7094 XCAP.EVEN_D_BUF.n13 XCAP.EVEN_D_BUF.t6 0.228
R7095 XCAP.EVEN_D_BUF.n15 XCAP.EVEN_D_BUF.t3 0.228
R7096 XCAP.EVEN_D_BUF.n15 XCAP.EVEN_D_BUF.t4 0.228
R7097 XCAP.EVEN_D_BUF.n17 XCAP.EVEN_D_BUF.t1 0.228
R7098 XCAP.EVEN_D_BUF.n17 XCAP.EVEN_D_BUF.t2 0.228
R7099 XCAP.EVEN_D_BUF.n20 XCAP.EVEN_D_BUF.t9 0.20525
R7100 XCAP.EVEN_D_BUF.n20 XCAP.EVEN_D_BUF.t10 0.20525
R7101 XCAP.EVEN_D_BUF.n16 XCAP.EVEN_D_BUF.n14 0.189974
R7102 XCAP.EVEN_D_BUF.n5 XCAP.EVEN_D_BUF.n0 0.1205
R7103 XCAP.EVEN_D_BUF.n11 XCAP.EVEN_D_BUF.n6 0.1205
R7104 XCAP.EVEN_D_BUF.n19 XCAP.EVEN_D_BUF.n18 0.0952368
R7105 XCAP.EVEN_D_BUF.n19 XCAP.EVEN_D_BUF.n16 0.0952368
R7106 XCAP.EVEN_D_BUF.n22 XCAP.EVEN_D_BUF.n21 0.0952368
R7107 XCAP.EVEN_D_BUF XCAP.EVEN_D_BUF.n24 0.0396304
C0 XFRONT.XFE_O.H VDD 16.7985f
C1 XCAP.O_QBI O_CAPTURE_CLK 0.04327f
C2 RX_RAWP O_SENSE_BOOST 0.07703f
C3 VDD O_CAPTURE_CLK 2.31414f
C4 XCAP.O_QI XCAP.O_SET_TAIL 0.48793f
C5 XCAP.E_QBI EVEN_QB 0.15538f
C6 XFRONT.XFE_E.H VDD 16.7985f
C7 XCAP.O_QBBUF ODD_Q 4.18276f
C8 XCAP.ODD_DB_BUF XCAP.O_SET_TAIL 0.54226f
C9 XCAP.EVEN_DB_BUF XCAP.E_RST_TAIL 0.50524f
C10 XCAP.O_QBI ODD_QB 0.15666f
C11 XFRONT.XFE_E.NTAIL E_SENSE_BOOST 5.37348f
C12 E_CAPTURE_CLKB FE_E_N 0.12139f
C13 XFRONT.XFE_E.HB VDD 16.1006f
C14 VDD ODD_QB 7.42733f
C15 XCAP.EVEN_D_BUF E_CAPTURE_CLK 0.10379f
C16 XCAP.E_QI XCAP.E_RST_TAIL 4.88428f
C17 XCAP.EVEN_D_BUF EVEN_QB 0.13958f
C18 XCAP.O_PRST_TAIL ODD_QB 0.43511f
C19 XCAP.O_QI XCAP.O_PSET_TAIL 5.10737f
C20 XFRONT.XFE_O.XP VDD 25.819f
C21 XCAP.EVEN_DB_BUF FE_E_N 0.03347f
C22 XCAP.EVEN_DB_BUF XCAP.E_SET_TAIL 0.71109f
C23 XCAP.ODD_DB_BUF XCAP.O_PSET_TAIL 0.68175f
C24 VDD E_SENSE_CLK 21.2686f
C25 XCAP.E_PSET_TAIL E_CAPTURE_CLKB 3.32426f
C26 XFRONT.XFE_O.XN VDD 25.3962f
C27 VDD TERM_EN6_N 1.78028f
C28 FE_O_N O_REGEN_CLKB 0.02948f
C29 XCAP.ODD_D_BUF O_CAPTURE_CLK 0.0367f
C30 XCAP.E_QI FE_E_N 0.51981f
C31 XCAP.E_QI XCAP.E_SET_TAIL 0.76857f
C32 XFRONT.XFE_E.XN VDD 25.3962f
C33 TERM_EN4_N TERM_EN3_N 0.0465f
C34 RX_BW_EN_N VTHP 0.14867f
C35 E_CAPTURE_CLK E_REGEN_CLKB 0.0323f
C36 XCAP.ODD_DB_BUF XCAP.O_QI 3.71826f
C37 XCAP.EVEN_DB_BUF XCAP.E_PSET_TAIL 1.81361f
C38 XCAP.ODD_D_BUF ODD_QB 0.15391f
C39 XFRONT.XFE_O.H FE_O_P 1.28169f
C40 VDD ODD_Q 7.41927f
C41 XFRONT.XFE_E.XP VDD 25.819f
C42 FE_O_P O_CAPTURE_CLK 0.2426f
C43 O_CAPTURE_CLKB O_CAPTURE_CLK 3.14354f
C44 XCAP.E_QI XCAP.E_PSET_TAIL 5.13429f
C45 XCAP.O_QBI XCAP.O_RST_TAIL 0.0736f
C46 XCAP.EVEN_DB_BUF E_CAPTURE_CLKB 0.19022f
C47 FE_E_N FE_E_P 5.07494f
C48 VDD O_SENSE_CLK 21.2686f
C49 XCAP.O_QBUF XCAP.O_PSET_TAIL 0.04525f
C50 VDD TERM_EN5_N 1.84084f
C51 ODD_QB FE_O_P 0.10247f
C52 O_CAPTURE_CLKB ODD_QB 0.10357f
C53 XCAP.E_QI E_CAPTURE_CLKB 0.15555f
C54 FE_O_N O_REGEN_CLK 0.01097f
C55 RXP RXN 0.4911f
C56 XCAP.E_QBBUF FE_E_N 0.14911f
C57 XCAP.O_QBI XCAP.O_SET_TAIL 4.91815f
C58 XCAP.O_QBBUF XCAP.O_QI 0.68141f
C59 XFRONT.XFE_E.NIP E_SENSE_BOOST 0.21857f
C60 E_CAPTURE_CLK E_REGEN_CLK 0.01576f
C61 XCAP.E_QI XCAP.EVEN_DB_BUF 3.57751f
C62 XFRONT.XFE_E.NIN E_SENSE_BOOST 0.0301f
C63 XFRONT.XFE_O.NIN XFRONT.XFE_O.NTAIL 10.6347f
C64 VDD FE_E_N 8.20663f
C65 RX_RAWN E_SENSE_BOOST 0.07703f
C66 E_CAPTURE_CLKB FE_E_P 0.28348f
C67 XCAP.E_QBI XCAP.E_RST_TAIL 0.01355f
C68 XCAP.ODD_D_BUF XCAP.O_RST_TAIL 0.70292f
C69 XCAP.O_QBI XCAP.O_PSET_TAIL 0.30508f
C70 XFRONT.XFE_O.NIP XFRONT.XFE_O.NTAIL 10.1886f
C71 XCAP.O_PSET_TAIL VDD 13.1964f
C72 VDD RX_RAWP 1.46674f
C73 VDD TERM_EN4_N 1.84084f
C74 XCAP.O_PRST_TAIL XCAP.O_PSET_TAIL 1.05443f
C75 O_CAPTURE_CLKB ODD_Q 0.07511f
C76 XCAP.E_PSET_TAIL VDD 11.6748f
C77 XCAP.E_QBBUF E_CAPTURE_CLKB 0.15018f
C78 XCAP.EVEN_DB_BUF FE_E_P 3.50536f
C79 RX_RAWN RX_BW_EN_N 0.35734f
C80 TERM_EN3_N TERM_EN2_N 0.0465f
C81 XCAP.EVEN_D_BUF XCAP.E_RST_TAIL 0.37995f
C82 XCAP.E_QBI XCAP.E_SET_TAIL 4.91367f
C83 XCAP.ODD_D_BUF XCAP.O_SET_TAIL 0.53742f
C84 XCAP.O_QBI XCAP.O_QI 8.49253f
C85 XFRONT.XFE_E.NIP XFRONT.XFE_E.NTAIL 10.1886f
C86 XCAP.O_RST_TAIL FE_O_P 0.16401f
C87 XCAP.O_QI VDD 7.2336f
C88 XCAP.E_QI FE_E_P 0.09054f
C89 VDD E_CAPTURE_CLKB 10.4624f
C90 XFRONT.XFE_O.NTAIL RX_RAWN 1.55309f
C91 XFRONT.XFE_O.HB FE_O_N 1.39766f
C92 XCAP.O_QBI XCAP.ODD_DB_BUF 0.19065f
C93 XCAP.E_QBUF XCAP.E_QI 0.06057f
C94 XCAP.O_PRST_TAIL XCAP.O_QI 0.29363f
C95 XCAP.E_PRST_TAIL XCAP.E_PSET_TAIL 1.95856f
C96 XFRONT.XFE_E.NIN XFRONT.XFE_E.NTAIL 10.6347f
C97 XCAP.ODD_DB_BUF VDD 13.0218f
C98 XFRONT.XFE_E.NTAIL RX_RAWN 2.27268f
C99 XCAP.EVEN_D_BUF FE_E_N 3.45509f
C100 XCAP.O_PRST_TAIL XCAP.ODD_DB_BUF 0.86137f
C101 XCAP.EVEN_D_BUF XCAP.E_SET_TAIL 0.61506f
C102 XCAP.E_QBI XCAP.E_PSET_TAIL 0.20078f
C103 XCAP.E_QBBUF XCAP.E_QI 0.60128f
C104 XCAP.ODD_D_BUF XCAP.O_PSET_TAIL 1.09217f
C105 XCAP.EVEN_DB_BUF VDD 12.9418f
C106 XCAP.E_PRST_TAIL E_CAPTURE_CLKB 0.94605f
C107 VDD TERM_EN3_N 1.84084f
C108 FE_O_N O_CAPTURE_CLK 0.52074f
C109 E_SENSE_CLK E_SENSE_BOOST 6.47808f
C110 XFRONT.XFE_O.HB XFRONT.XFE_O.DN 2.12721f
C111 XCAP.E_QI VDD 7.23216f
C112 XCAP.E_QBI E_CAPTURE_CLKB 0.12357f
C113 O_CAPTURE_CLK O_REGEN_CLKB 0.0323f
C114 ODD_QB FE_O_N 0.09326f
C115 XCAP.EVEN_D_BUF XCAP.E_PSET_TAIL 0.4182f
C116 XCAP.E_PRST_TAIL XCAP.EVEN_DB_BUF 0.13174f
C117 XCAP.ODD_D_BUF XCAP.O_QI 0.70423f
C118 XFRONT.XFE_O.H XFRONT.XFE_O.DN 0.66623f
C119 XFRONT.XFE_O.HB XFRONT.XFE_O.DP 0.75819f
C120 RXP TERM_EN6_N 0.32905f
C121 RX_BIAS RXP 0.89265f
C122 XCAP.O_PSET_TAIL O_CAPTURE_CLKB 2.02608f
C123 XCAP.O_QBBUF VDD 6.75866f
C124 XCAP.ODD_D_BUF XCAP.ODD_DB_BUF 1.07149f
C125 XCAP.E_QBI XCAP.EVEN_DB_BUF 0.0643f
C126 XCAP.O_QBI XCAP.O_QBUF 1.08164f
C127 XCAP.E_PRST_TAIL XCAP.E_QI 0.2741f
C128 XFRONT.XFE_O.H XFRONT.XFE_O.DP 2.1383f
C129 EVEN_Q EVEN_QB 0.47433f
C130 XCAP.EVEN_D_BUF E_CAPTURE_CLKB 0.42228f
C131 XCAP.O_QBUF VDD 6.35692f
C132 VDD FE_E_P 8.0906f
C133 VDD TERM_EN2_N 1.84084f
C134 XCAP.E_QBI XCAP.E_QI 8.54354f
C135 XCAP.O_PRST_TAIL XCAP.O_QBUF 1.54979f
C136 XCAP.O_QI FE_O_P 0.12934f
C137 XCAP.O_QI O_CAPTURE_CLKB 0.15737f
C138 XCAP.E_QBUF VDD 7.45153f
C139 XFRONT.XFE_O.NIN RX_RAWN 2.30328f
C140 XCAP.EVEN_D_BUF XCAP.EVEN_DB_BUF 0.97829f
C141 XFRONT.XFE_E.NTAIL E_SENSE_CLK 1.32172f
C142 XFRONT.XFE_O.XP XFRONT.XFE_O.DN 0.04432f
C143 XFRONT.XFE_E.H XFRONT.XFE_E.DP 2.1383f
C144 XFRONT.XFE_O.HB XFRONT.XFE_O.NIN 0.07207f
C145 TERM_EN2_N TERM_EN1_N 0.0465f
C146 XCAP.ODD_DB_BUF FE_O_P 3.64424f
C147 XCAP.ODD_DB_BUF O_CAPTURE_CLKB 0.81461f
C148 O_CAPTURE_CLK O_REGEN_CLK 0.01576f
C149 XCAP.E_QBBUF VDD 6.44257f
C150 RXP TERM_EN5_N 0.3225f
C151 XCAP.EVEN_D_BUF XCAP.E_QI 0.74882f
C152 XCAP.ODD_D_BUF XCAP.O_QBBUF 2.37715f
C153 XCAP.E_PRST_TAIL XCAP.E_QBUF 0.53754f
C154 XFRONT.XFE_O.HB XFRONT.XFE_O.NIP 0.07069f
C155 XFRONT.XFE_O.XN XFRONT.XFE_O.DN 2.15469f
C156 XFRONT.XFE_O.H XFRONT.XFE_O.NIN 0.07808f
C157 XFRONT.XFE_O.XP XFRONT.XFE_O.DP 2.21809f
C158 XFRONT.XFE_E.HB XFRONT.XFE_E.DP 0.75819f
C159 XFRONT.XFE_E.H XFRONT.XFE_E.DN 0.66623f
C160 XCAP.O_QBI VDD 8.61871f
C161 XFRONT.XFE_E.NIP RX_RAWN 1.58284f
C162 VDD VTHN 0.44639f
C163 XCAP.E_QBI XCAP.E_QBUF 0.99299f
C164 XCAP.ODD_D_BUF XCAP.O_QBUF 0.28842f
C165 XCAP.O_PRST_TAIL XCAP.O_QBI 5.53402f
C166 XFRONT.XFE_O.H XFRONT.XFE_O.NIP 0.07683f
C167 XFRONT.XFE_E.HB XFRONT.XFE_E.DN 2.12721f
C168 XCAP.O_PRST_TAIL VDD 15.3528f
C169 VDD TERM_EN1_N 1.84084f
C170 XFRONT.XFE_O.NTAIL O_SENSE_CLK 1.32172f
C171 XFRONT.XFE_E.DP E_SENSE_CLK 0.29923f
C172 XCAP.O_QBBUF O_CAPTURE_CLKB 0.16758f
C173 XCAP.E_PRST_TAIL VDD 16.0686f
C174 RX_RAWP E_SENSE_BOOST 0.07735f
C175 XCAP.EVEN_D_BUF FE_E_P 0.04189f
C176 XFRONT.XFE_E.DN E_SENSE_CLK 0.18071f
C177 XFRONT.XFE_O.XP XFRONT.XFE_O.NIN 2.21087f
C178 XFRONT.XFE_E.H XFRONT.XFE_E.NIP 0.07683f
C179 XCAP.E_QBI VDD 8.57345f
C180 RXP TERM_EN4_N 0.3225f
C181 XFRONT.XFE_O.DN O_SENSE_CLK 0.18071f
C182 XFRONT.XFE_O.H RX_RAWN 0.01013f
C183 XCAP.EVEN_D_BUF XCAP.E_QBBUF 2.27875f
C184 XCAP.ODD_D_BUF XCAP.O_QBI 4.78972f
C185 XFRONT.XFE_E.XP XFRONT.XFE_E.DP 2.21809f
C186 XFRONT.XFE_O.XP XFRONT.XFE_O.NIP 14.4614f
C187 XFRONT.XFE_E.XN XFRONT.XFE_E.DN 2.15469f
C188 XFRONT.XFE_O.H XFRONT.XFE_O.HB 7.51355f
C189 XFRONT.XFE_O.XN XFRONT.XFE_O.NIN 14.5465f
C190 XFRONT.XFE_E.HB XFRONT.XFE_E.NIP 0.07069f
C191 XFRONT.XFE_E.H XFRONT.XFE_E.NIN 0.07808f
C192 RX_RAWP RX_BW_EN_N 0.3734f
C193 XCAP.ODD_D_BUF VDD 15.601f
C194 XFRONT.XFE_O.NTAIL O_SENSE_BOOST 5.37348f
C195 XFRONT.XFE_E.H RX_RAWN 0.01013f
C196 XFRONT.XFE_O.DP O_SENSE_CLK 0.29923f
C197 RX_BIAS RXN 0.36689f
C198 XCAP.ODD_D_BUF XCAP.O_PRST_TAIL 0.78807f
C199 XCAP.E_QBI XCAP.E_PRST_TAIL 5.5293f
C200 XFRONT.XFE_O.XN XFRONT.XFE_O.NIP 2.86849f
C201 XFRONT.XFE_E.XP XFRONT.XFE_E.DN 0.04432f
C202 XFRONT.XFE_E.HB XFRONT.XFE_E.NIN 0.07207f
C203 XCAP.EVEN_D_BUF VDD 14.4594f
C204 VDD TERM_EN0_N 1.71963f
C205 XFRONT.XFE_O.NTAIL RX_RAWP 2.27268f
C206 XFRONT.XFE_E.NIP E_SENSE_CLK 2.64521f
C207 FE_E_P E_REGEN_CLKB 0.02948f
C208 XCAP.O_QBI O_CAPTURE_CLKB 0.07731f
C209 XFRONT.XFE_E.NTAIL RX_RAWP 1.55309f
C210 TERM_EN1_N TERM_EN0_N 0.0465f
C211 VDD FE_O_P 8.1209f
C212 VDD O_CAPTURE_CLKB 10.298f
C213 XCAP.O_QI FE_O_N 0.57789f
C214 XCAP.EVEN_D_BUF XCAP.E_PRST_TAIL 3.77728f
C215 XFRONT.XFE_E.NIN E_SENSE_CLK 2.60237f
C216 RXP TERM_EN3_N 0.3225f
C217 XFRONT.XFE_O.XP XFRONT.XFE_O.HB 3.58406f
C218 XFRONT.XFE_E.XN XFRONT.XFE_E.NIP 2.86849f
C219 XCAP.O_PRST_TAIL O_CAPTURE_CLKB 3.41065f
C220 E_SENSE_CLK RX_RAWN 0.40197f
C221 XFRONT.XFE_O.NIN O_SENSE_CLK 2.60237f
C222 XCAP.EVEN_D_BUF XCAP.E_QBI 4.77076f
C223 XFRONT.XFE_E.HB XFRONT.XFE_E.H 7.51355f
C224 XFRONT.XFE_O.XP XFRONT.XFE_O.H 0.82467f
C225 XFRONT.XFE_E.XP XFRONT.XFE_E.NIP 14.4614f
C226 XFRONT.XFE_O.XN XFRONT.XFE_O.HB 0.56886f
C227 XFRONT.XFE_E.XN XFRONT.XFE_E.NIN 14.5465f
C228 XFRONT.XFE_O.NIP O_SENSE_CLK 2.64521f
C229 VDD E_REGEN_CLKB 0.12239f
C230 XFRONT.XFE_O.XN XFRONT.XFE_O.H 1.91259f
C231 XFRONT.XFE_E.XP XFRONT.XFE_E.NIN 2.21087f
C232 FE_E_P E_REGEN_CLK 0.01097f
C233 XFRONT.XFE_E.H E_SENSE_CLK 1.23646f
C234 XCAP.ODD_D_BUF FE_O_P 0.02446f
C235 XCAP.ODD_D_BUF O_CAPTURE_CLKB 0.70031f
C236 XCAP.E_RST_TAIL E_CAPTURE_CLK 1.16209f
C237 XFRONT.XFE_O.NIN O_SENSE_BOOST 0.0301f
C238 RXP TERM_EN2_N 0.3225f
C239 XCAP.O_QBBUF FE_O_N 0.20592f
C240 XFRONT.XFE_E.HB E_SENSE_CLK 2.31435f
C241 XFRONT.XFE_E.XN XFRONT.XFE_E.H 1.91259f
C242 O_SENSE_CLK RX_RAWN 5.46787f
C243 XFRONT.XFE_O.NIP O_SENSE_BOOST 0.21857f
C244 XFRONT.XFE_O.HB O_SENSE_CLK 2.31435f
C245 XFRONT.XFE_E.XN XFRONT.XFE_E.HB 0.56886f
C246 XFRONT.XFE_O.XN XFRONT.XFE_O.XP 22.8576f
C247 XFRONT.XFE_E.XP XFRONT.XFE_E.H 0.82467f
C248 XFRONT.XFE_O.NIP RX_RAWP 1.58284f
C249 FE_E_N E_CAPTURE_CLK 0.51259f
C250 XCAP.E_SET_TAIL E_CAPTURE_CLK 1.75694f
C251 E_CAPTURE_CLKB EVEN_Q 0.10117f
C252 VDD E_REGEN_CLK 0.13137f
C253 XFRONT.XFE_O.H O_SENSE_CLK 1.23646f
C254 XCAP.O_RST_TAIL O_CAPTURE_CLK 2.06628f
C255 EVEN_QB FE_E_N 0.06902f
C256 ODD_QB ODD_Q 0.51937f
C257 XFRONT.XFE_E.XP XFRONT.XFE_E.HB 3.58406f
C258 VDD RXP 0.72204f
C259 XFRONT.XFE_E.XN E_SENSE_CLK 5.09008f
C260 RX_RAWN O_SENSE_BOOST 0.07735f
C261 XFRONT.XFE_E.NIN RX_RAWP 2.30328f
C262 VDD RX_BW_EN_N 3.18648f
C263 RXP TERM_EN1_N 0.30522f
C264 RX_BW_EN_N VTHN 0.14867f
C265 XCAP.O_SET_TAIL O_CAPTURE_CLK 1.51208f
C266 RX_RAWP RX_RAWN 12.717f
C267 XFRONT.XFE_E.XP E_SENSE_CLK 5.70356f
C268 VDD FE_O_N 8.03136f
C269 XCAP.E_PSET_TAIL EVEN_QB 0.02064f
C270 XFRONT.XFE_O.XP O_SENSE_CLK 5.70356f
C271 E_CAPTURE_CLKB E_CAPTURE_CLK 2.97032f
C272 XFRONT.XFE_E.H FE_E_N 1.28169f
C273 XFRONT.XFE_E.XP XFRONT.XFE_E.XN 22.8576f
C274 VDD O_REGEN_CLKB 0.12239f
C275 XFRONT.XFE_O.H RX_RAWP 0.01013f
C276 E_CAPTURE_CLKB EVEN_QB 0.70057f
C277 XFRONT.XFE_O.XN O_SENSE_CLK 5.09008f
C278 TERM_EN6_N TERM_EN5_N 0.0465f
C279 XFRONT.XFE_E.H RX_RAWP 0.01013f
C280 XFRONT.XFE_O.DN VDD 6.18388f
C281 XCAP.EVEN_DB_BUF E_CAPTURE_CLK 0.15269f
C282 VDD VTHP 0.44639f
C283 RXP TERM_EN0_N 0.29398f
C284 XCAP.EVEN_DB_BUF EVEN_QB 0.15519f
C285 XCAP.O_PSET_TAIL ODD_QB 0.21495f
C286 VTHP VTHN 0.71747f
C287 XCAP.E_QI E_CAPTURE_CLK 0.1853f
C288 XFRONT.XFE_O.DP VDD 6.18171f
C289 XCAP.O_QI O_CAPTURE_CLK 0.16467f
C290 XCAP.ODD_D_BUF FE_O_N 3.44145f
C291 XCAP.E_QI EVEN_QB 0.33632f
C292 XCAP.E_QBBUF EVEN_Q 4.25991f
C293 XFRONT.XFE_E.DP VDD 6.18171f
C294 XCAP.ODD_DB_BUF O_CAPTURE_CLK 0.32291f
C295 VDD O_REGEN_CLK 0.13137f
C296 XCAP.O_QI ODD_QB 0.23682f
C297 E_SENSE_CLK RX_RAWP 5.46787f
C298 XFRONT.XFE_E.DN VDD 6.18388f
C299 VDD EVEN_Q 7.31561f
C300 FE_E_P E_CAPTURE_CLK 0.45212f
C301 FE_O_P FE_O_N 1.55504f
C302 O_CAPTURE_CLKB FE_O_N 0.16306f
C303 XCAP.O_SET_TAIL XCAP.O_RST_TAIL 0.70351f
C304 XCAP.ODD_DB_BUF ODD_QB 0.17063f
C305 XFRONT.XFE_O.NIN VDD 6.7829f
C306 EVEN_QB FE_E_P 0.07547f
C307 XCAP.E_QBUF EVEN_QB 4.13702f
C308 XFRONT.XFE_O.NIP VDD 6.70406f
C309 XCAP.E_RST_TAIL FE_E_N 0.01318f
C310 XCAP.E_SET_TAIL XCAP.E_RST_TAIL 0.57545f
C311 XCAP.E_QBBUF EVEN_QB 0.17621f
C312 O_SENSE_CLK O_SENSE_BOOST 6.47808f
C313 XFRONT.XFE_E.NIP VDD 6.70406f
C314 VDD E_CAPTURE_CLK 2.31373f
C315 O_SENSE_CLK RX_RAWP 0.40197f
C316 XCAP.O_QBBUF ODD_QB 0.15023f
C317 XFRONT.XFE_E.NIN VDD 6.7829f
C318 VDD EVEN_QB 8.86516f
C319 TERM_EN5_N TERM_EN4_N 0.0465f
C320 VDD RX_RAWN 1.37416f
C321 XCAP.O_QBUF ODD_QB 4.17728f
C322 XCAP.O_QI XCAP.O_RST_TAIL 4.94403f
C323 XFRONT.XFE_O.HB VDD 16.1006f
C324 XFRONT.XFE_E.HB FE_E_P 1.39766f
C325 XCAP.E_PRST_TAIL EVEN_QB 0.0844f
C326 XCAP.ODD_DB_BUF XCAP.O_RST_TAIL 0.56945f
C327 O_REGEN_CLK VSS 0.09722f
C328 O_REGEN_CLKB VSS 0.08114f
C329 E_REGEN_CLK VSS 0.09722f
C330 E_REGEN_CLKB VSS 0.08114f
C331 TERM_EN0_N VSS 3.16281f
C332 TERM_EN1_N VSS 2.58106f
C333 TERM_EN2_N VSS 2.56583f
C334 TERM_EN3_N VSS 2.56561f
C335 TERM_EN4_N VSS 2.56561f
C336 TERM_EN5_N VSS 2.56561f
C337 TERM_EN6_N VSS 2.69513f
C338 RXN VSS 15.23621f
C339 RXP VSS 15.16766f
C340 RX_BIAS VSS 13.3368f
C341 VTHN VSS 2.67742f
C342 VTHP VSS 2.67769f
C343 RX_BW_EN_N VSS 3.53422f
C344 O_SENSE_BOOST VSS 19.08508f
C345 E_SENSE_BOOST VSS 19.08508f
C346 RX_RAWN VSS 26.45293f
C347 RX_RAWP VSS 26.37508f
C348 O_SENSE_CLK VSS 17.67546f
C349 E_SENSE_CLK VSS 17.67546f
C350 O_CAPTURE_CLK VSS 22.83357f
C351 E_CAPTURE_CLK VSS 25.51307f
C352 FE_O_N VSS 27.10526f
C353 FE_O_P VSS 32.87134f
C354 FE_E_P VSS 36.84045f
C355 FE_E_N VSS 25.94806f
C356 ODD_Q VSS 5.29541f
C357 ODD_QB VSS 9.73643f
C358 EVEN_QB VSS 9.40271f
C359 EVEN_Q VSS 5.60206f
C360 O_CAPTURE_CLKB VSS 20.68858f
C361 E_CAPTURE_CLKB VSS 23.09587f
C362 VDD VSS 4.62023p
C363 XFRONT.XFE_O.NTAIL VSS 46.98668f
C364 XFRONT.XFE_E.NTAIL VSS 47.47016f
C365 XFRONT.XFE_O.DN VSS 9.84723f
C366 XFRONT.XFE_O.DP VSS 9.85739f
C367 XFRONT.XFE_E.DP VSS 10.10227f
C368 XFRONT.XFE_E.DN VSS 10.19211f
C369 XFRONT.XFE_O.NIN VSS 3.76356f
C370 XFRONT.XFE_O.NIP VSS 3.47617f
C371 XFRONT.XFE_E.NIP VSS 4.35051f
C372 XFRONT.XFE_E.NIN VSS 5.165f
C373 XFRONT.XFE_O.HB VSS 19.64067f
C374 XFRONT.XFE_O.H VSS 20.30146f
C375 XFRONT.XFE_E.H VSS 20.61385f
C376 XFRONT.XFE_E.HB VSS 20.35346f
C377 XFRONT.XFE_O.XP VSS 10.75778f
C378 XFRONT.XFE_O.XN VSS 11.15447f
C379 XFRONT.XFE_E.XN VSS 13.06891f
C380 XFRONT.XFE_E.XP VSS 12.33217f
C381 XCAP.O_RST_TAIL VSS 14.07771f
C382 XCAP.E_RST_TAIL VSS 13.40099f
C383 XCAP.O_SET_TAIL VSS 11.53561f
C384 XCAP.E_SET_TAIL VSS 11.52819f
C385 XCAP.O_PSET_TAIL VSS 0.23222f
C386 XCAP.E_PSET_TAIL VSS 0.15708f
C387 XCAP.O_QI VSS 12.92219f
C388 XCAP.ODD_DB_BUF VSS 9.95341f
C389 XCAP.EVEN_DB_BUF VSS 10.21596f
C390 XCAP.E_QI VSS 12.05784f
C391 XCAP.O_QBBUF VSS 5.49643f
C392 XCAP.O_QBUF VSS 5.2576f
C393 XCAP.E_QBUF VSS 5.25384f
C394 XCAP.E_QBBUF VSS 6.1426f
C395 XCAP.O_QBI VSS 10.93681f
C396 XCAP.O_PRST_TAIL VSS 0.25427f
C397 XCAP.E_PRST_TAIL VSS 0.70236f
C398 XCAP.E_QBI VSS 11.57233f
C399 XCAP.ODD_D_BUF VSS 9.0285f
C400 XCAP.EVEN_D_BUF VSS 9.21535f
C401 XCAP.EVEN_D_BUF.n0 VSS 0.33788f
C402 XCAP.EVEN_D_BUF.n1 VSS 0.16701f
C403 XCAP.EVEN_D_BUF.n2 VSS 0.17902f
C404 XCAP.EVEN_D_BUF.n3 VSS 0.17902f
C405 XCAP.EVEN_D_BUF.n4 VSS 0.16919f
C406 XCAP.EVEN_D_BUF.n5 VSS 2.35913f
C407 XCAP.EVEN_D_BUF.n6 VSS 0.33788f
C408 XCAP.EVEN_D_BUF.n7 VSS 0.16701f
C409 XCAP.EVEN_D_BUF.n8 VSS 0.17902f
C410 XCAP.EVEN_D_BUF.n9 VSS 0.17902f
C411 XCAP.EVEN_D_BUF.n10 VSS 0.16919f
C412 XCAP.EVEN_D_BUF.n11 VSS 1.74907f
C413 XCAP.EVEN_D_BUF.n12 VSS 6.49511f
C414 XCAP.EVEN_D_BUF.t7 VSS 1.36247f
C415 XCAP.EVEN_D_BUF.t6 VSS 0.26183f
C416 XCAP.EVEN_D_BUF.t5 VSS 0.26183f
C417 XCAP.EVEN_D_BUF.n13 VSS 1.05804f
C418 XCAP.EVEN_D_BUF.n14 VSS 0.58157f
C419 XCAP.EVEN_D_BUF.t4 VSS 0.26183f
C420 XCAP.EVEN_D_BUF.t3 VSS 0.26183f
C421 XCAP.EVEN_D_BUF.n15 VSS 1.05804f
C422 XCAP.EVEN_D_BUF.n16 VSS 0.24385f
C423 XCAP.EVEN_D_BUF.t0 VSS 1.36247f
C424 XCAP.EVEN_D_BUF.t2 VSS 0.26183f
C425 XCAP.EVEN_D_BUF.t1 VSS 0.26183f
C426 XCAP.EVEN_D_BUF.n17 VSS 1.05804f
C427 XCAP.EVEN_D_BUF.n18 VSS 0.52182f
C428 XCAP.EVEN_D_BUF.n19 VSS 0.11987f
C429 XCAP.EVEN_D_BUF.t11 VSS 1.35995f
C430 XCAP.EVEN_D_BUF.t10 VSS 0.26183f
C431 XCAP.EVEN_D_BUF.t9 VSS 0.26183f
C432 XCAP.EVEN_D_BUF.n20 VSS 1.05024f
C433 XCAP.EVEN_D_BUF.n21 VSS 0.53215f
C434 XCAP.EVEN_D_BUF.t8 VSS 1.35427f
C435 XCAP.EVEN_D_BUF.n22 VSS 1.1256f
C436 XCAP.EVEN_D_BUF.n23 VSS 2.00092f
C437 XCAP.EVEN_D_BUF.n24 VSS 0.91313f
C438 XCAP.ODD_D_BUF.t11 VSS 1.32633f
C439 XCAP.ODD_D_BUF.t10 VSS 0.25325f
C440 XCAP.ODD_D_BUF.t9 VSS 0.25325f
C441 XCAP.ODD_D_BUF.n0 VSS 1.02634f
C442 XCAP.ODD_D_BUF.n1 VSS 0.52004f
C443 XCAP.ODD_D_BUF.t8 VSS 1.32079f
C444 XCAP.ODD_D_BUF.n2 VSS 1.10721f
C445 XCAP.ODD_D_BUF.t7 VSS 1.3288f
C446 XCAP.ODD_D_BUF.t6 VSS 0.25325f
C447 XCAP.ODD_D_BUF.t5 VSS 0.25325f
C448 XCAP.ODD_D_BUF.n3 VSS 1.03396f
C449 XCAP.ODD_D_BUF.n4 VSS 0.56834f
C450 XCAP.ODD_D_BUF.t4 VSS 0.25325f
C451 XCAP.ODD_D_BUF.t3 VSS 0.25325f
C452 XCAP.ODD_D_BUF.n5 VSS 1.03396f
C453 XCAP.ODD_D_BUF.n6 VSS 0.2383f
C454 XCAP.ODD_D_BUF.t0 VSS 1.3288f
C455 XCAP.ODD_D_BUF.t2 VSS 0.25325f
C456 XCAP.ODD_D_BUF.t1 VSS 0.25325f
C457 XCAP.ODD_D_BUF.n7 VSS 1.03396f
C458 XCAP.ODD_D_BUF.n8 VSS 0.50995f
C459 XCAP.ODD_D_BUF.n9 VSS 0.11678f
C460 XCAP.ODD_D_BUF.n10 VSS 2.49974f
C461 XCAP.ODD_D_BUF.n11 VSS 0.33019f
C462 XCAP.ODD_D_BUF.n12 VSS 0.16321f
C463 XCAP.ODD_D_BUF.n13 VSS 0.17494f
C464 XCAP.ODD_D_BUF.n14 VSS 0.17494f
C465 XCAP.ODD_D_BUF.n15 VSS 0.16534f
C466 XCAP.ODD_D_BUF.n16 VSS 1.68886f
C467 XCAP.ODD_D_BUF.n17 VSS 3.87043f
C468 XCAP.ODD_D_BUF.n18 VSS 0.33019f
C469 XCAP.ODD_D_BUF.n19 VSS 0.16321f
C470 XCAP.ODD_D_BUF.n20 VSS 0.17494f
C471 XCAP.ODD_D_BUF.n21 VSS 0.17494f
C472 XCAP.ODD_D_BUF.n22 VSS 0.16534f
C473 XCAP.ODD_D_BUF.n23 VSS 2.03803f
C474 XCAP.ODD_D_BUF.n24 VSS 3.5691f
C475 XCAP.E_QBI.n0 VSS 0.84803f
C476 XCAP.E_QBI.n1 VSS 0.44045f
C477 XCAP.E_QBI.n2 VSS 3.21925f
C478 XCAP.E_QBI.t5 VSS 1.32226f
C479 XCAP.E_QBI.t4 VSS 1.31381f
C480 XCAP.E_QBI.n3 VSS 1.04291f
C481 XCAP.E_QBI.t7 VSS 1.32002f
C482 XCAP.E_QBI.t6 VSS 1.31155f
C483 XCAP.E_QBI.n4 VSS 0.5077f
C484 XCAP.E_QBI.n5 VSS 1.57463f
C485 XCAP.E_QBI.t0 VSS 1.33522f
C486 XCAP.E_QBI.t1 VSS 0.35565f
C487 XCAP.E_QBI.t8 VSS 0.35565f
C488 XCAP.E_QBI.n6 VSS 0.9346f
C489 XCAP.E_QBI.n7 VSS 0.47356f
C490 XCAP.E_QBI.t9 VSS 1.32683f
C491 XCAP.E_QBI.n8 VSS 0.51261f
C492 XCAP.E_QBI.n9 VSS 0.96021f
C493 XCAP.E_QBI.n10 VSS 1.88012f
C494 XCAP.E_QBI.t10 VSS 1.33746f
C495 XCAP.E_QBI.t11 VSS 0.35565f
C496 XCAP.E_QBI.t2 VSS 0.35565f
C497 XCAP.E_QBI.n11 VSS 0.94155f
C498 XCAP.E_QBI.t3 VSS 1.33412f
C499 XCAP.E_QBI.n12 VSS 2.12356f
C500 XCAP.E_QBI.n13 VSS 0.42173f
C501 XCAP.E_QBI.n14 VSS 3.48843f
C502 XCAP.E_QBI.n15 VSS 0.44926f
C503 XCAP.E_QBI.n16 VSS 1.3761f
C504 XCAP.E_QBI.n17 VSS 0.45859f
C505 XCAP.E_PRST_TAIL.t4 VSS 1.66159f
C506 XCAP.E_PRST_TAIL.t6 VSS 0.31491f
C507 XCAP.E_PRST_TAIL.t5 VSS 0.31491f
C508 XCAP.E_PRST_TAIL.n0 VSS 1.29586f
C509 XCAP.E_PRST_TAIL.n1 VSS 0.71229f
C510 XCAP.E_PRST_TAIL.t8 VSS 0.31491f
C511 XCAP.E_PRST_TAIL.t7 VSS 0.31491f
C512 XCAP.E_PRST_TAIL.n2 VSS 1.29586f
C513 XCAP.E_PRST_TAIL.n3 VSS 0.37183f
C514 XCAP.E_PRST_TAIL.t10 VSS 0.31491f
C515 XCAP.E_PRST_TAIL.t9 VSS 0.31491f
C516 XCAP.E_PRST_TAIL.n4 VSS 1.29586f
C517 XCAP.E_PRST_TAIL.n5 VSS 0.37183f
C518 XCAP.E_PRST_TAIL.t11 VSS 1.65121f
C519 XCAP.E_PRST_TAIL.n6 VSS 5.16751f
C520 XCAP.E_PRST_TAIL.t2 VSS 0.42743f
C521 XCAP.E_PRST_TAIL.t3 VSS 0.4241f
C522 XCAP.E_PRST_TAIL.n7 VSS 1.30601f
C523 XCAP.E_PRST_TAIL.t0 VSS 0.4241f
C524 XCAP.E_PRST_TAIL.t1 VSS 0.4241f
C525 XCAP.E_PRST_TAIL.n8 VSS 1.29586f
C526 XCAP.E_PRST_TAIL.n9 VSS 3.3314f
C527 XCAP.E_PRST_TAIL.n10 VSS 7.14958f
C528 XCAP.O_PRST_TAIL.t0 VSS 0.45317f
C529 XCAP.O_PRST_TAIL.t2 VSS 0.45317f
C530 XCAP.O_PRST_TAIL.n0 VSS 1.47829f
C531 XCAP.O_PRST_TAIL.t3 VSS 0.45317f
C532 XCAP.O_PRST_TAIL.t1 VSS 0.45643f
C533 XCAP.O_PRST_TAIL.n1 VSS 1.4668f
C534 XCAP.O_PRST_TAIL.n2 VSS 3.90634f
C535 XCAP.O_PRST_TAIL.t11 VSS 1.88733f
C536 XCAP.O_PRST_TAIL.t10 VSS 0.36151f
C537 XCAP.O_PRST_TAIL.t9 VSS 0.36151f
C538 XCAP.O_PRST_TAIL.n3 VSS 1.4668f
C539 XCAP.O_PRST_TAIL.n4 VSS 0.80625f
C540 XCAP.O_PRST_TAIL.t8 VSS 0.36151f
C541 XCAP.O_PRST_TAIL.t7 VSS 0.36151f
C542 XCAP.O_PRST_TAIL.n5 VSS 1.4668f
C543 XCAP.O_PRST_TAIL.n6 VSS 0.42088f
C544 XCAP.O_PRST_TAIL.t6 VSS 0.36151f
C545 XCAP.O_PRST_TAIL.t5 VSS 0.36151f
C546 XCAP.O_PRST_TAIL.n7 VSS 1.4668f
C547 XCAP.O_PRST_TAIL.n8 VSS 0.42088f
C548 XCAP.O_PRST_TAIL.t4 VSS 1.87268f
C549 XCAP.O_PRST_TAIL.n9 VSS 3.44009f
C550 XCAP.O_PRST_TAIL.n10 VSS 6.46887f
C551 XCAP.O_QBI.t6 VSS 1.36529f
C552 XCAP.O_QBI.t10 VSS 0.3572f
C553 XCAP.O_QBI.t11 VSS 0.3572f
C554 XCAP.O_QBI.n0 VSS 0.97004f
C555 XCAP.O_QBI.t7 VSS 1.36855f
C556 XCAP.O_QBI.n1 VSS 2.18783f
C557 XCAP.O_QBI.n2 VSS 0.4345f
C558 XCAP.O_QBI.n3 VSS 3.47797f
C559 XCAP.O_QBI.n4 VSS 0.48595f
C560 XCAP.O_QBI.n5 VSS 1.71164f
C561 XCAP.O_QBI.t2 VSS 1.35633f
C562 XCAP.O_QBI.t1 VSS 1.34763f
C563 XCAP.O_QBI.n6 VSS 1.04242f
C564 XCAP.O_QBI.t0 VSS 1.36624f
C565 XCAP.O_QBI.t8 VSS 0.3572f
C566 XCAP.O_QBI.t9 VSS 0.3572f
C567 XCAP.O_QBI.n7 VSS 0.96289f
C568 XCAP.O_QBI.n8 VSS 0.48789f
C569 XCAP.O_QBI.t5 VSS 1.35778f
C570 XCAP.O_QBI.n9 VSS 0.57498f
C571 XCAP.O_QBI.t4 VSS 1.35402f
C572 XCAP.O_QBI.t3 VSS 1.3453f
C573 XCAP.O_QBI.n10 VSS 0.52306f
C574 XCAP.O_QBI.n11 VSS 1.05845f
C575 XCAP.O_QBI.n12 VSS 1.53829f
C576 XCAP.O_QBI.n13 VSS 1.50493f
C577 XCAP.O_QBI.n14 VSS 0.8737f
C578 XCAP.O_QBI.n15 VSS 0.45378f
C579 XCAP.O_QBI.n16 VSS 2.72459f
C580 XCAP.O_QBI.n17 VSS 0.66575f
C581 XCAP.E_QBBUF.t1 VSS 1.15837f
C582 XCAP.E_QBBUF.t0 VSS 1.15114f
C583 XCAP.E_QBBUF.n0 VSS 1.11868f
C584 XCAP.E_QBBUF.t3 VSS 0.55609f
C585 XCAP.E_QBBUF.t2 VSS 0.54973f
C586 XCAP.E_QBBUF.n1 VSS 0.49446f
C587 XCAP.E_QBBUF.n2 VSS 2.10122f
C588 XCAP.E_QBBUF.n3 VSS 0.12582f
C589 XCAP.E_QBBUF.n4 VSS 0.13681f
C590 XCAP.E_QBBUF.n5 VSS 0.13681f
C591 XCAP.E_QBBUF.n6 VSS 0.12582f
C592 XCAP.E_QBBUF.n7 VSS 1.1405f
C593 XCAP.E_QBBUF.n8 VSS 0.12979f
C594 XCAP.E_QBBUF.n9 VSS 0.13681f
C595 XCAP.E_QBBUF.n10 VSS 0.1247f
C596 XCAP.E_QBBUF.n11 VSS 0.29031f
C597 XCAP.E_QBBUF.n12 VSS 2.47221f
C598 XCAP.E_QBBUF.n13 VSS 0.71331f
C599 XCAP.E_QBUF.t1 VSS 1.10555f
C600 XCAP.E_QBUF.t0 VSS 1.09867f
C601 XCAP.E_QBUF.n0 VSS 1.06423f
C602 XCAP.E_QBUF.t3 VSS 0.53094f
C603 XCAP.E_QBUF.t2 VSS 0.52489f
C604 XCAP.E_QBUF.n1 VSS 0.47039f
C605 XCAP.E_QBUF.n2 VSS 1.92533f
C606 XCAP.E_QBUF.n3 VSS 0.11969f
C607 XCAP.E_QBUF.n4 VSS 0.13015f
C608 XCAP.E_QBUF.n5 VSS 0.13015f
C609 XCAP.E_QBUF.n6 VSS 0.11969f
C610 XCAP.E_QBUF.n7 VSS 1.08499f
C611 XCAP.E_QBUF.n8 VSS 0.12347f
C612 XCAP.E_QBUF.n9 VSS 0.13015f
C613 XCAP.E_QBUF.n10 VSS 0.11863f
C614 XCAP.E_QBUF.n11 VSS 0.27618f
C615 XCAP.E_QBUF.n12 VSS 2.26498f
C616 XCAP.E_QBUF.n13 VSS 0.65507f
C617 XCAP.O_QBUF.n0 VSS 0.12253f
C618 XCAP.O_QBUF.n1 VSS 0.13323f
C619 XCAP.O_QBUF.n2 VSS 0.13323f
C620 XCAP.O_QBUF.n3 VSS 0.12253f
C621 XCAP.O_QBUF.n4 VSS 1.04857f
C622 XCAP.O_QBUF.n5 VSS 0.12639f
C623 XCAP.O_QBUF.n6 VSS 0.13323f
C624 XCAP.O_QBUF.n7 VSS 0.12143f
C625 XCAP.O_QBUF.n8 VSS 0.28917f
C626 XCAP.O_QBUF.n9 VSS 2.53404f
C627 XCAP.O_QBUF.t2 VSS 1.13276f
C628 XCAP.O_QBUF.t3 VSS 1.12572f
C629 XCAP.O_QBUF.n10 VSS 1.08943f
C630 XCAP.O_QBUF.t0 VSS 0.54407f
C631 XCAP.O_QBUF.t1 VSS 0.53788f
C632 XCAP.O_QBUF.n11 VSS 0.48153f
C633 XCAP.O_QBUF.n12 VSS 1.70254f
C634 XCAP.O_QBUF.n13 VSS 0.78588f
C635 XCAP.O_QBBUF.n0 VSS 0.13089f
C636 XCAP.O_QBBUF.n1 VSS 0.14232f
C637 XCAP.O_QBBUF.n2 VSS 0.14232f
C638 XCAP.O_QBBUF.n3 VSS 0.13089f
C639 XCAP.O_QBBUF.n4 VSS 1.1571f
C640 XCAP.O_QBBUF.n5 VSS 0.13501f
C641 XCAP.O_QBBUF.n6 VSS 0.14232f
C642 XCAP.O_QBBUF.n7 VSS 0.12972f
C643 XCAP.O_QBBUF.n8 VSS 0.30396f
C644 XCAP.O_QBBUF.n9 VSS 2.67488f
C645 XCAP.O_QBBUF.t1 VSS 1.19746f
C646 XCAP.O_QBBUF.t0 VSS 1.18994f
C647 XCAP.O_QBBUF.n10 VSS 1.16376f
C648 XCAP.O_QBBUF.t3 VSS 0.57442f
C649 XCAP.O_QBBUF.t2 VSS 0.5678f
C650 XCAP.O_QBBUF.n11 VSS 0.51438f
C651 XCAP.O_QBBUF.n12 VSS 1.90408f
C652 XCAP.O_QBBUF.n13 VSS 0.85474f
C653 XCAP.E_QI.n0 VSS 0.63071f
C654 XCAP.E_QI.n1 VSS 0.4523f
C655 XCAP.E_QI.n2 VSS 2.36392f
C656 XCAP.E_QI.t7 VSS 1.34372f
C657 XCAP.E_QI.t6 VSS 0.33558f
C658 XCAP.E_QI.t5 VSS 0.33558f
C659 XCAP.E_QI.n3 VSS 0.96735f
C660 XCAP.E_QI.n4 VSS 0.47709f
C661 XCAP.E_QI.t4 VSS 1.33569f
C662 XCAP.E_QI.n5 VSS 0.57107f
C663 XCAP.E_QI.t10 VSS 1.34974f
C664 XCAP.E_QI.t8 VSS 1.34106f
C665 XCAP.E_QI.n6 VSS 0.51698f
C666 XCAP.E_QI.n7 VSS 2.04742f
C667 XCAP.E_QI.t9 VSS 1.34743f
C668 XCAP.E_QI.t11 VSS 1.33874f
C669 XCAP.E_QI.n8 VSS 0.52161f
C670 XCAP.E_QI.n9 VSS 1.16549f
C671 XCAP.E_QI.t3 VSS 1.34141f
C672 XCAP.E_QI.t2 VSS 0.33558f
C673 XCAP.E_QI.t1 VSS 0.33558f
C674 XCAP.E_QI.n10 VSS 0.96022f
C675 XCAP.E_QI.n11 VSS 0.48653f
C676 XCAP.E_QI.t0 VSS 1.33338f
C677 XCAP.E_QI.n12 VSS 0.83247f
C678 XCAP.E_QI.n13 VSS 1.61475f
C679 XCAP.E_QI.n14 VSS 1.78179f
C680 XCAP.E_QI.n15 VSS 0.81564f
C681 XCAP.E_QI.n16 VSS 0.40416f
C682 XCAP.E_QI.n17 VSS 2.91991f
C683 XCAP.E_QI.n18 VSS 1.0207f
C684 XCAP.EVEN_DB_BUF.n0 VSS 0.28915f
C685 XCAP.EVEN_DB_BUF.n1 VSS 0.14292f
C686 XCAP.EVEN_DB_BUF.n2 VSS 0.1532f
C687 XCAP.EVEN_DB_BUF.n3 VSS 0.1532f
C688 XCAP.EVEN_DB_BUF.n4 VSS 0.14479f
C689 XCAP.EVEN_DB_BUF.n5 VSS 0.28522f
C690 XCAP.EVEN_DB_BUF.n6 VSS 0.28915f
C691 XCAP.EVEN_DB_BUF.n7 VSS 0.14292f
C692 XCAP.EVEN_DB_BUF.n8 VSS 0.1532f
C693 XCAP.EVEN_DB_BUF.n9 VSS 0.1532f
C694 XCAP.EVEN_DB_BUF.n10 VSS 0.14479f
C695 XCAP.EVEN_DB_BUF.n11 VSS 1.62002f
C696 XCAP.EVEN_DB_BUF.n12 VSS 4.02077f
C697 XCAP.EVEN_DB_BUF.t11 VSS 1.16942f
C698 XCAP.EVEN_DB_BUF.t10 VSS 0.22956f
C699 XCAP.EVEN_DB_BUF.t9 VSS 0.22956f
C700 XCAP.EVEN_DB_BUF.n13 VSS 0.89878f
C701 XCAP.EVEN_DB_BUF.n14 VSS 0.45541f
C702 XCAP.EVEN_DB_BUF.t8 VSS 1.16456f
C703 XCAP.EVEN_DB_BUF.n15 VSS 0.9696f
C704 XCAP.EVEN_DB_BUF.t7 VSS 1.17158f
C705 XCAP.EVEN_DB_BUF.t6 VSS 0.22956f
C706 XCAP.EVEN_DB_BUF.t5 VSS 0.22956f
C707 XCAP.EVEN_DB_BUF.n16 VSS 0.90546f
C708 XCAP.EVEN_DB_BUF.n17 VSS 0.4977f
C709 XCAP.EVEN_DB_BUF.t4 VSS 0.22956f
C710 XCAP.EVEN_DB_BUF.t3 VSS 0.22956f
C711 XCAP.EVEN_DB_BUF.n18 VSS 0.90546f
C712 XCAP.EVEN_DB_BUF.n19 VSS 0.20868f
C713 XCAP.EVEN_DB_BUF.t0 VSS 1.17158f
C714 XCAP.EVEN_DB_BUF.t2 VSS 0.22956f
C715 XCAP.EVEN_DB_BUF.t1 VSS 0.22956f
C716 XCAP.EVEN_DB_BUF.n20 VSS 0.90546f
C717 XCAP.EVEN_DB_BUF.n21 VSS 0.44657f
C718 XCAP.EVEN_DB_BUF.n22 VSS 0.10226f
C719 XCAP.EVEN_DB_BUF.n23 VSS 1.79544f
C720 XCAP.EVEN_DB_BUF.n24 VSS 0.71112f
C721 XCAP.ODD_DB_BUF.t11 VSS 1.18222f
C722 XCAP.ODD_DB_BUF.t10 VSS 0.22796f
C723 XCAP.ODD_DB_BUF.t9 VSS 0.22796f
C724 XCAP.ODD_DB_BUF.n0 VSS 0.91264f
C725 XCAP.ODD_DB_BUF.n1 VSS 0.46243f
C726 XCAP.ODD_DB_BUF.t8 VSS 1.17729f
C727 XCAP.ODD_DB_BUF.n2 VSS 0.98455f
C728 XCAP.ODD_DB_BUF.t7 VSS 1.1844f
C729 XCAP.ODD_DB_BUF.t6 VSS 0.22796f
C730 XCAP.ODD_DB_BUF.t5 VSS 0.22796f
C731 XCAP.ODD_DB_BUF.n3 VSS 0.91942f
C732 XCAP.ODD_DB_BUF.n4 VSS 0.50537f
C733 XCAP.ODD_DB_BUF.t4 VSS 0.22796f
C734 XCAP.ODD_DB_BUF.t3 VSS 0.22796f
C735 XCAP.ODD_DB_BUF.n5 VSS 0.91942f
C736 XCAP.ODD_DB_BUF.n6 VSS 0.2119f
C737 XCAP.ODD_DB_BUF.t0 VSS 1.1844f
C738 XCAP.ODD_DB_BUF.t2 VSS 0.22796f
C739 XCAP.ODD_DB_BUF.t1 VSS 0.22796f
C740 XCAP.ODD_DB_BUF.n7 VSS 0.91942f
C741 XCAP.ODD_DB_BUF.n8 VSS 0.45345f
C742 XCAP.ODD_DB_BUF.n9 VSS 0.10384f
C743 XCAP.ODD_DB_BUF.n10 VSS 2.21745f
C744 XCAP.ODD_DB_BUF.n11 VSS 0.29361f
C745 XCAP.ODD_DB_BUF.n12 VSS 0.14513f
C746 XCAP.ODD_DB_BUF.n13 VSS 0.15556f
C747 XCAP.ODD_DB_BUF.n14 VSS 0.15556f
C748 XCAP.ODD_DB_BUF.n15 VSS 0.14702f
C749 XCAP.ODD_DB_BUF.n16 VSS 0.26874f
C750 XCAP.ODD_DB_BUF.n17 VSS 0.29361f
C751 XCAP.ODD_DB_BUF.n18 VSS 0.14513f
C752 XCAP.ODD_DB_BUF.n19 VSS 0.15556f
C753 XCAP.ODD_DB_BUF.n20 VSS 0.15556f
C754 XCAP.ODD_DB_BUF.n21 VSS 0.14702f
C755 XCAP.ODD_DB_BUF.n22 VSS 1.73534f
C756 XCAP.ODD_DB_BUF.n23 VSS 3.87678f
C757 XCAP.ODD_DB_BUF.n24 VSS 0.93564f
C758 XCAP.O_QI.n0 VSS 0.81035f
C759 XCAP.O_QI.n1 VSS 0.40154f
C760 XCAP.O_QI.n2 VSS 3.28197f
C761 XCAP.O_QI.t6 VSS 1.33831f
C762 XCAP.O_QI.t0 VSS 0.33666f
C763 XCAP.O_QI.t1 VSS 0.33666f
C764 XCAP.O_QI.n3 VSS 0.96107f
C765 XCAP.O_QI.n4 VSS 0.474f
C766 XCAP.O_QI.t2 VSS 1.33027f
C767 XCAP.O_QI.n5 VSS 0.56737f
C768 XCAP.O_QI.t9 VSS 1.34677f
C769 XCAP.O_QI.t10 VSS 1.33815f
C770 XCAP.O_QI.n6 VSS 0.51362f
C771 XCAP.O_QI.n7 VSS 2.03413f
C772 XCAP.O_QI.t3 VSS 1.34448f
C773 XCAP.O_QI.t4 VSS 1.33584f
C774 XCAP.O_QI.n8 VSS 0.51822f
C775 XCAP.O_QI.n9 VSS 1.04296f
C776 XCAP.O_QI.t11 VSS 1.33602f
C777 XCAP.O_QI.t7 VSS 0.33666f
C778 XCAP.O_QI.t8 VSS 0.33666f
C779 XCAP.O_QI.n10 VSS 0.95398f
C780 XCAP.O_QI.n11 VSS 0.48338f
C781 XCAP.O_QI.t5 VSS 1.32798f
C782 XCAP.O_QI.n12 VSS 0.91671f
C783 XCAP.O_QI.n13 VSS 1.6296f
C784 XCAP.O_QI.n14 VSS 2.1671f
C785 XCAP.O_QI.n15 VSS 0.58411f
C786 XCAP.O_QI.n16 VSS 0.46929f
C787 XCAP.O_QI.n17 VSS 2.17206f
C788 XCAP.O_QI.n18 VSS 0.4681f
C789 XCAP.E_PSET_TAIL.t11 VSS 1.97219f
C790 XCAP.E_PSET_TAIL.t10 VSS 0.3634f
C791 XCAP.E_PSET_TAIL.t9 VSS 0.3634f
C792 XCAP.E_PSET_TAIL.n0 VSS 1.54688f
C793 XCAP.E_PSET_TAIL.n1 VSS 0.85027f
C794 XCAP.E_PSET_TAIL.t8 VSS 0.3634f
C795 XCAP.E_PSET_TAIL.t7 VSS 0.3634f
C796 XCAP.E_PSET_TAIL.n2 VSS 1.54688f
C797 XCAP.E_PSET_TAIL.n3 VSS 0.44386f
C798 XCAP.E_PSET_TAIL.t6 VSS 0.3634f
C799 XCAP.E_PSET_TAIL.t5 VSS 0.3634f
C800 XCAP.E_PSET_TAIL.n4 VSS 1.54688f
C801 XCAP.E_PSET_TAIL.n5 VSS 0.44386f
C802 XCAP.E_PSET_TAIL.t4 VSS 1.95707f
C803 XCAP.E_PSET_TAIL.n6 VSS 2.2193f
C804 XCAP.E_PSET_TAIL.t2 VSS 0.45039f
C805 XCAP.E_PSET_TAIL.t0 VSS 0.44754f
C806 XCAP.E_PSET_TAIL.n7 VSS 1.55899f
C807 XCAP.E_PSET_TAIL.t1 VSS 0.44754f
C808 XCAP.E_PSET_TAIL.t3 VSS 0.44754f
C809 XCAP.E_PSET_TAIL.n8 VSS 1.54688f
C810 XCAP.E_PSET_TAIL.n9 VSS 2.2126f
C811 XCAP.E_PSET_TAIL.n10 VSS 3.81367f
C812 XCAP.O_PSET_TAIL.t1 VSS 0.43217f
C813 XCAP.O_PSET_TAIL.t2 VSS 0.43217f
C814 XCAP.O_PSET_TAIL.n0 VSS 1.46688f
C815 XCAP.O_PSET_TAIL.t3 VSS 0.43507f
C816 XCAP.O_PSET_TAIL.t0 VSS 0.43217f
C817 XCAP.O_PSET_TAIL.n1 VSS 1.45549f
C818 XCAP.O_PSET_TAIL.n2 VSS 2.74646f
C819 XCAP.O_PSET_TAIL.t11 VSS 1.8734f
C820 XCAP.O_PSET_TAIL.t10 VSS 0.35932f
C821 XCAP.O_PSET_TAIL.t9 VSS 0.35932f
C822 XCAP.O_PSET_TAIL.n3 VSS 1.45549f
C823 XCAP.O_PSET_TAIL.n4 VSS 0.80004f
C824 XCAP.O_PSET_TAIL.t8 VSS 0.35932f
C825 XCAP.O_PSET_TAIL.t7 VSS 0.35932f
C826 XCAP.O_PSET_TAIL.n5 VSS 1.45549f
C827 XCAP.O_PSET_TAIL.n6 VSS 0.41764f
C828 XCAP.O_PSET_TAIL.t6 VSS 0.35932f
C829 XCAP.O_PSET_TAIL.t5 VSS 0.35932f
C830 XCAP.O_PSET_TAIL.n7 VSS 1.45549f
C831 XCAP.O_PSET_TAIL.n8 VSS 0.41764f
C832 XCAP.O_PSET_TAIL.t4 VSS 1.85884f
C833 XCAP.O_PSET_TAIL.n9 VSS 1.58693f
C834 XCAP.O_PSET_TAIL.n10 VSS 4.05229f
C835 XCAP.E_SET_TAIL.t2 VSS 0.3085f
C836 XCAP.E_SET_TAIL.t3 VSS 0.3085f
C837 XCAP.E_SET_TAIL.n0 VSS 0.69793f
C838 XCAP.E_SET_TAIL.t0 VSS 0.31184f
C839 XCAP.E_SET_TAIL.t1 VSS 0.3085f
C840 XCAP.E_SET_TAIL.n1 VSS 0.69236f
C841 XCAP.E_SET_TAIL.n2 VSS 0.55269f
C842 XCAP.E_SET_TAIL.t11 VSS 0.89358f
C843 XCAP.E_SET_TAIL.t10 VSS 0.16972f
C844 XCAP.E_SET_TAIL.t9 VSS 0.16972f
C845 XCAP.E_SET_TAIL.n3 VSS 0.69236f
C846 XCAP.E_SET_TAIL.n4 VSS 0.3902f
C847 XCAP.E_SET_TAIL.t8 VSS 0.16972f
C848 XCAP.E_SET_TAIL.t7 VSS 0.16972f
C849 XCAP.E_SET_TAIL.n5 VSS 0.69236f
C850 XCAP.E_SET_TAIL.n6 VSS 0.20528f
C851 XCAP.E_SET_TAIL.t4 VSS 0.89358f
C852 XCAP.E_SET_TAIL.t6 VSS 0.16972f
C853 XCAP.E_SET_TAIL.t5 VSS 0.16972f
C854 XCAP.E_SET_TAIL.n7 VSS 0.69236f
C855 XCAP.E_SET_TAIL.n8 VSS 0.59761f
C856 XCAP.E_SET_TAIL.n9 VSS 1.04754f
C857 XCAP.O_SET_TAIL.t11 VSS 0.87759f
C858 XCAP.O_SET_TAIL.t10 VSS 0.17439f
C859 XCAP.O_SET_TAIL.t9 VSS 0.17439f
C860 XCAP.O_SET_TAIL.n0 VSS 0.67242f
C861 XCAP.O_SET_TAIL.n1 VSS 0.37897f
C862 XCAP.O_SET_TAIL.t8 VSS 0.17439f
C863 XCAP.O_SET_TAIL.t7 VSS 0.17439f
C864 XCAP.O_SET_TAIL.n2 VSS 0.67242f
C865 XCAP.O_SET_TAIL.n3 VSS 0.19937f
C866 XCAP.O_SET_TAIL.t4 VSS 0.87759f
C867 XCAP.O_SET_TAIL.t6 VSS 0.17439f
C868 XCAP.O_SET_TAIL.t5 VSS 0.17439f
C869 XCAP.O_SET_TAIL.n4 VSS 0.67242f
C870 XCAP.O_SET_TAIL.n5 VSS 0.55941f
C871 XCAP.O_SET_TAIL.t3 VSS 0.30067f
C872 XCAP.O_SET_TAIL.t1 VSS 0.30067f
C873 XCAP.O_SET_TAIL.n6 VSS 0.67784f
C874 XCAP.O_SET_TAIL.t0 VSS 0.30393f
C875 XCAP.O_SET_TAIL.t2 VSS 0.30067f
C876 XCAP.O_SET_TAIL.n7 VSS 0.67242f
C877 XCAP.O_SET_TAIL.n8 VSS 0.49654f
C878 XCAP.O_SET_TAIL.n9 VSS 0.70815f
C879 XCAP.E_RST_TAIL.t9 VSS 0.69236f
C880 XCAP.E_RST_TAIL.t8 VSS 0.13822f
C881 XCAP.E_RST_TAIL.t7 VSS 0.13822f
C882 XCAP.E_RST_TAIL.n0 VSS 0.53051f
C883 XCAP.E_RST_TAIL.n1 VSS 0.29899f
C884 XCAP.E_RST_TAIL.t6 VSS 0.13822f
C885 XCAP.E_RST_TAIL.t5 VSS 0.13822f
C886 XCAP.E_RST_TAIL.n2 VSS 0.53051f
C887 XCAP.E_RST_TAIL.n3 VSS 0.1573f
C888 XCAP.E_RST_TAIL.t4 VSS 0.13822f
C889 XCAP.E_RST_TAIL.t3 VSS 0.13822f
C890 XCAP.E_RST_TAIL.n4 VSS 0.53051f
C891 XCAP.E_RST_TAIL.n5 VSS 0.12712f
C892 XCAP.E_RST_TAIL.t2 VSS 0.69017f
C893 XCAP.E_RST_TAIL.n6 VSS 0.39357f
C894 XCAP.E_RST_TAIL.t11 VSS 0.25195f
C895 XCAP.E_RST_TAIL.t0 VSS 0.25195f
C896 XCAP.E_RST_TAIL.n7 VSS 0.53478f
C897 XCAP.E_RST_TAIL.t1 VSS 0.2548f
C898 XCAP.E_RST_TAIL.t10 VSS 0.25195f
C899 XCAP.E_RST_TAIL.n8 VSS 0.53051f
C900 XCAP.E_RST_TAIL.n9 VSS 0.74529f
C901 XCAP.E_RST_TAIL.n10 VSS 0.79743f
C902 XCAP.O_RST_TAIL.t2 VSS 0.26572f
C903 XCAP.O_RST_TAIL.t0 VSS 0.26572f
C904 XCAP.O_RST_TAIL.n0 VSS 0.59423f
C905 XCAP.O_RST_TAIL.t3 VSS 0.26861f
C906 XCAP.O_RST_TAIL.t1 VSS 0.26572f
C907 XCAP.O_RST_TAIL.n1 VSS 0.58949f
C908 XCAP.O_RST_TAIL.n2 VSS 1.09562f
C909 XCAP.O_RST_TAIL.t11 VSS 0.77399f
C910 XCAP.O_RST_TAIL.t10 VSS 0.15825f
C911 XCAP.O_RST_TAIL.t9 VSS 0.15825f
C912 XCAP.O_RST_TAIL.n3 VSS 0.58949f
C913 XCAP.O_RST_TAIL.n4 VSS 0.33223f
C914 XCAP.O_RST_TAIL.t8 VSS 0.15825f
C915 XCAP.O_RST_TAIL.t7 VSS 0.15825f
C916 XCAP.O_RST_TAIL.n5 VSS 0.58949f
C917 XCAP.O_RST_TAIL.n6 VSS 0.17478f
C918 XCAP.O_RST_TAIL.t6 VSS 0.15825f
C919 XCAP.O_RST_TAIL.t5 VSS 0.15825f
C920 XCAP.O_RST_TAIL.n7 VSS 0.58949f
C921 XCAP.O_RST_TAIL.n8 VSS 0.14125f
C922 XCAP.O_RST_TAIL.t4 VSS 0.77164f
C923 XCAP.O_RST_TAIL.n9 VSS 0.46717f
C924 XCAP.O_RST_TAIL.n10 VSS 1.44128f
C925 XFRONT.XFE_E.XP.t17 VSS 1.38791f
C926 XFRONT.XFE_E.XP.t8 VSS 1.3992f
C927 XFRONT.XFE_E.XP.t10 VSS 0.29876f
C928 XFRONT.XFE_E.XP.t9 VSS 0.29876f
C929 XFRONT.XFE_E.XP.n0 VSS 1.05643f
C930 XFRONT.XFE_E.XP.n1 VSS 0.58069f
C931 XFRONT.XFE_E.XP.t12 VSS 0.29876f
C932 XFRONT.XFE_E.XP.t11 VSS 0.29876f
C933 XFRONT.XFE_E.XP.n2 VSS 1.05643f
C934 XFRONT.XFE_E.XP.n3 VSS 0.30313f
C935 XFRONT.XFE_E.XP.t14 VSS 0.29876f
C936 XFRONT.XFE_E.XP.t13 VSS 0.29876f
C937 XFRONT.XFE_E.XP.n4 VSS 1.05643f
C938 XFRONT.XFE_E.XP.n5 VSS 0.30313f
C939 XFRONT.XFE_E.XP.t16 VSS 0.29876f
C940 XFRONT.XFE_E.XP.t15 VSS 0.29876f
C941 XFRONT.XFE_E.XP.n6 VSS 1.05643f
C942 XFRONT.XFE_E.XP.n7 VSS 0.28822f
C943 XFRONT.XFE_E.XP.n8 VSS 1.55768f
C944 XFRONT.XFE_E.XP.n9 VSS 0.33737f
C945 XFRONT.XFE_E.XP.n10 VSS 0.16675f
C946 XFRONT.XFE_E.XP.n11 VSS 0.17874f
C947 XFRONT.XFE_E.XP.n12 VSS 0.17874f
C948 XFRONT.XFE_E.XP.n13 VSS 0.16893f
C949 XFRONT.XFE_E.XP.n14 VSS 1.42089f
C950 XFRONT.XFE_E.XP.n15 VSS 0.24239f
C951 XFRONT.XFE_E.XP.n16 VSS 0.25025f
C952 XFRONT.XFE_E.XP.n17 VSS 0.25025f
C953 XFRONT.XFE_E.XP.n18 VSS 0.17874f
C954 XFRONT.XFE_E.XP.n19 VSS 0.11591f
C955 XFRONT.XFE_E.XP.n20 VSS 0.11591f
C956 XFRONT.XFE_E.XP.n21 VSS 0.33737f
C957 XFRONT.XFE_E.XP.n22 VSS 0.25051f
C958 XFRONT.XFE_E.XP.n23 VSS 0.25051f
C959 XFRONT.XFE_E.XP.n24 VSS 0.25051f
C960 XFRONT.XFE_E.XP.n25 VSS 0.25051f
C961 XFRONT.XFE_E.XP.n26 VSS 0.25051f
C962 XFRONT.XFE_E.XP.n27 VSS 0.4949f
C963 XFRONT.XFE_E.XP.n28 VSS 0.16675f
C964 XFRONT.XFE_E.XP.n29 VSS 0.17874f
C965 XFRONT.XFE_E.XP.n30 VSS 0.17874f
C966 XFRONT.XFE_E.XP.n31 VSS 0.17874f
C967 XFRONT.XFE_E.XP.n32 VSS 0.17874f
C968 XFRONT.XFE_E.XP.n33 VSS 0.17874f
C969 XFRONT.XFE_E.XP.n34 VSS 0.11591f
C970 XFRONT.XFE_E.XP.n35 VSS 0.11591f
C971 XFRONT.XFE_E.XP.n36 VSS 0.11565f
C972 XFRONT.XFE_E.XP.n37 VSS 0.17874f
C973 XFRONT.XFE_E.XP.n38 VSS 0.17874f
C974 XFRONT.XFE_E.XP.n39 VSS 0.4949f
C975 XFRONT.XFE_E.XP.n40 VSS 0.16675f
C976 XFRONT.XFE_E.XP.n41 VSS 0.3371f
C977 XFRONT.XFE_E.XP.n42 VSS 0.17874f
C978 XFRONT.XFE_E.XP.n43 VSS 0.17874f
C979 XFRONT.XFE_E.XP.n44 VSS 0.29566f
C980 XFRONT.XFE_E.XP.n45 VSS 1.795f
C981 XFRONT.XFE_E.XP.n46 VSS 3.10172f
C982 XFRONT.XFE_E.XP.n47 VSS 1.47542f
C983 XFRONT.XFE_E.XP.n48 VSS 3.45737f
C984 XFRONT.XFE_E.XP.t7 VSS 1.3992f
C985 XFRONT.XFE_E.XP.t6 VSS 0.29876f
C986 XFRONT.XFE_E.XP.t5 VSS 0.29876f
C987 XFRONT.XFE_E.XP.n49 VSS 1.05643f
C988 XFRONT.XFE_E.XP.n50 VSS 0.52103f
C989 XFRONT.XFE_E.XP.t0 VSS 1.39919f
C990 XFRONT.XFE_E.XP.t2 VSS 0.29876f
C991 XFRONT.XFE_E.XP.t1 VSS 0.29876f
C992 XFRONT.XFE_E.XP.n51 VSS 1.05643f
C993 XFRONT.XFE_E.XP.n52 VSS 0.58069f
C994 XFRONT.XFE_E.XP.t4 VSS 0.29876f
C995 XFRONT.XFE_E.XP.t3 VSS 0.29876f
C996 XFRONT.XFE_E.XP.n53 VSS 1.05643f
C997 XFRONT.XFE_E.XP.n54 VSS 0.24348f
C998 XFRONT.XFE_E.XP.n55 VSS 1.37228f
C999 XFRONT.XFE_E.XP.n56 VSS 2.05638f
C1000 XFRONT.XFE_E.XP.t31 VSS 1.47571f
C1001 XFRONT.XFE_E.XP.t30 VSS 1.47329f
C1002 XFRONT.XFE_E.XP.n57 VSS 2.36091f
C1003 XFRONT.XFE_E.XP.n58 VSS 2.92298f
C1004 XFRONT.XFE_E.XP.t29 VSS 1.43044f
C1005 XFRONT.XFE_E.XP.t28 VSS 0.33163f
C1006 XFRONT.XFE_E.XP.t27 VSS 0.33163f
C1007 XFRONT.XFE_E.XP.n59 VSS 1.04864f
C1008 XFRONT.XFE_E.XP.n60 VSS 0.591f
C1009 XFRONT.XFE_E.XP.t26 VSS 0.33163f
C1010 XFRONT.XFE_E.XP.t25 VSS 0.33163f
C1011 XFRONT.XFE_E.XP.n61 VSS 1.04864f
C1012 XFRONT.XFE_E.XP.n62 VSS 0.25126f
C1013 XFRONT.XFE_E.XP.t18 VSS 1.43044f
C1014 XFRONT.XFE_E.XP.t20 VSS 0.33163f
C1015 XFRONT.XFE_E.XP.t19 VSS 0.33163f
C1016 XFRONT.XFE_E.XP.n63 VSS 1.04864f
C1017 XFRONT.XFE_E.XP.n64 VSS 0.591f
C1018 XFRONT.XFE_E.XP.t22 VSS 0.33163f
C1019 XFRONT.XFE_E.XP.t21 VSS 0.33163f
C1020 XFRONT.XFE_E.XP.n65 VSS 1.04864f
C1021 XFRONT.XFE_E.XP.n66 VSS 0.31092f
C1022 XFRONT.XFE_E.XP.t24 VSS 0.33163f
C1023 XFRONT.XFE_E.XP.t23 VSS 0.33163f
C1024 XFRONT.XFE_E.XP.n67 VSS 1.04864f
C1025 XFRONT.XFE_E.XP.n68 VSS 0.25126f
C1026 XFRONT.XFE_E.XP.n69 VSS 0.78552f
C1027 XFRONT.XFE_E.XP.n70 VSS 1.62307f
C1028 XFRONT.XFE_E.XP.n71 VSS 0.95385f
C1029 XFRONT.XFE_E.XP.n72 VSS 1.25315f
C1030 XFRONT.XFE_E.XP.n73 VSS 0.32704f
C1031 XFRONT.XFE_E.XP.n74 VSS 0.16675f
C1032 XFRONT.XFE_E.XP.n75 VSS 0.17874f
C1033 XFRONT.XFE_E.XP.n76 VSS 0.17874f
C1034 XFRONT.XFE_E.XP.n77 VSS 0.16904f
C1035 XFRONT.XFE_E.XP.n78 VSS 0.42062f
C1036 XFRONT.XFE_E.XP.n79 VSS 0.8627f
C1037 XFRONT.XFE_E.XN.n0 VSS 0.32954f
C1038 XFRONT.XFE_E.XN.n1 VSS 0.16803f
C1039 XFRONT.XFE_E.XN.n2 VSS 0.18011f
C1040 XFRONT.XFE_E.XN.n3 VSS 0.18011f
C1041 XFRONT.XFE_E.XN.n4 VSS 0.17033f
C1042 XFRONT.XFE_E.XN.n5 VSS 1.24336f
C1043 XFRONT.XFE_E.XN.t16 VSS 1.40913f
C1044 XFRONT.XFE_E.XN.t15 VSS 0.30031f
C1045 XFRONT.XFE_E.XN.t14 VSS 0.30031f
C1046 XFRONT.XFE_E.XN.n6 VSS 1.06449f
C1047 XFRONT.XFE_E.XN.n7 VSS 0.58512f
C1048 XFRONT.XFE_E.XN.t13 VSS 0.30031f
C1049 XFRONT.XFE_E.XN.t12 VSS 0.30031f
C1050 XFRONT.XFE_E.XN.n8 VSS 1.06449f
C1051 XFRONT.XFE_E.XN.n9 VSS 0.30545f
C1052 XFRONT.XFE_E.XN.t11 VSS 0.30031f
C1053 XFRONT.XFE_E.XN.t10 VSS 0.30031f
C1054 XFRONT.XFE_E.XN.n10 VSS 1.06449f
C1055 XFRONT.XFE_E.XN.n11 VSS 0.30545f
C1056 XFRONT.XFE_E.XN.t9 VSS 0.30031f
C1057 XFRONT.XFE_E.XN.t8 VSS 0.30031f
C1058 XFRONT.XFE_E.XN.n12 VSS 1.06449f
C1059 XFRONT.XFE_E.XN.n13 VSS 0.24533f
C1060 XFRONT.XFE_E.XN.t7 VSS 1.40085f
C1061 XFRONT.XFE_E.XN.n14 VSS 1.66511f
C1062 XFRONT.XFE_E.XN.n15 VSS 0.17033f
C1063 XFRONT.XFE_E.XN.n16 VSS 0.16803f
C1064 XFRONT.XFE_E.XN.n17 VSS 0.18011f
C1065 XFRONT.XFE_E.XN.n18 VSS 0.18011f
C1066 XFRONT.XFE_E.XN.n19 VSS 0.32954f
C1067 XFRONT.XFE_E.XN.n20 VSS 0.3775f
C1068 XFRONT.XFE_E.XN.n21 VSS 2.16471f
C1069 XFRONT.XFE_E.XN.n22 VSS 0.9973f
C1070 XFRONT.XFE_E.XN.n23 VSS 1.42665f
C1071 XFRONT.XFE_E.XN.t2 VSS 1.43937f
C1072 XFRONT.XFE_E.XN.t26 VSS 0.33222f
C1073 XFRONT.XFE_E.XN.t27 VSS 0.33222f
C1074 XFRONT.XFE_E.XN.n24 VSS 1.05664f
C1075 XFRONT.XFE_E.XN.n25 VSS 0.59551f
C1076 XFRONT.XFE_E.XN.t28 VSS 0.33222f
C1077 XFRONT.XFE_E.XN.t23 VSS 0.33222f
C1078 XFRONT.XFE_E.XN.n26 VSS 1.05664f
C1079 XFRONT.XFE_E.XN.n27 VSS 0.25318f
C1080 XFRONT.XFE_E.XN.t22 VSS 1.43937f
C1081 XFRONT.XFE_E.XN.t31 VSS 0.33222f
C1082 XFRONT.XFE_E.XN.t21 VSS 0.33222f
C1083 XFRONT.XFE_E.XN.n28 VSS 1.05664f
C1084 XFRONT.XFE_E.XN.n29 VSS 0.59551f
C1085 XFRONT.XFE_E.XN.t29 VSS 0.33222f
C1086 XFRONT.XFE_E.XN.t30 VSS 0.33222f
C1087 XFRONT.XFE_E.XN.n30 VSS 1.05664f
C1088 XFRONT.XFE_E.XN.n31 VSS 0.31329f
C1089 XFRONT.XFE_E.XN.t24 VSS 0.33222f
C1090 XFRONT.XFE_E.XN.t25 VSS 0.33222f
C1091 XFRONT.XFE_E.XN.n32 VSS 1.05664f
C1092 XFRONT.XFE_E.XN.n33 VSS 0.25318f
C1093 XFRONT.XFE_E.XN.n34 VSS 0.85518f
C1094 XFRONT.XFE_E.XN.n35 VSS 1.72642f
C1095 XFRONT.XFE_E.XN.t1 VSS 1.47912f
C1096 XFRONT.XFE_E.XN.t0 VSS 1.48871f
C1097 XFRONT.XFE_E.XN.n36 VSS 2.31351f
C1098 XFRONT.XFE_E.XN.n37 VSS 2.80884f
C1099 XFRONT.XFE_E.XN.t5 VSS 0.30289f
C1100 XFRONT.XFE_E.XN.t3 VSS 0.30031f
C1101 XFRONT.XFE_E.XN.n38 VSS 1.07282f
C1102 XFRONT.XFE_E.XN.t4 VSS 0.30031f
C1103 XFRONT.XFE_E.XN.t19 VSS 0.30031f
C1104 XFRONT.XFE_E.XN.n39 VSS 1.06449f
C1105 XFRONT.XFE_E.XN.n40 VSS 0.53944f
C1106 XFRONT.XFE_E.XN.t6 VSS 0.30031f
C1107 XFRONT.XFE_E.XN.t17 VSS 0.30031f
C1108 XFRONT.XFE_E.XN.n41 VSS 1.06449f
C1109 XFRONT.XFE_E.XN.t18 VSS 0.30031f
C1110 XFRONT.XFE_E.XN.t20 VSS 0.30288f
C1111 XFRONT.XFE_E.XN.n42 VSS 1.07282f
C1112 XFRONT.XFE_E.XN.n43 VSS 1.44722f
C1113 XFRONT.XFE_E.XN.n44 VSS 1.69004f
C1114 XFRONT.XFE_E.XN.n45 VSS 1.44329f
C1115 XFRONT.XFE_E.XN.n46 VSS 3.21788f
C1116 XFRONT.XFE_E.XN.n47 VSS 0.24424f
C1117 XFRONT.XFE_E.XN.n48 VSS 0.25216f
C1118 XFRONT.XFE_E.XN.n49 VSS 0.25216f
C1119 XFRONT.XFE_E.XN.n50 VSS 0.18011f
C1120 XFRONT.XFE_E.XN.n51 VSS 0.11679f
C1121 XFRONT.XFE_E.XN.n52 VSS 0.11679f
C1122 XFRONT.XFE_E.XN.n53 VSS 0.33994f
C1123 XFRONT.XFE_E.XN.n54 VSS 0.25242f
C1124 XFRONT.XFE_E.XN.n55 VSS 0.25242f
C1125 XFRONT.XFE_E.XN.n56 VSS 0.25242f
C1126 XFRONT.XFE_E.XN.n57 VSS 0.25242f
C1127 XFRONT.XFE_E.XN.n58 VSS 0.25242f
C1128 XFRONT.XFE_E.XN.n59 VSS 0.49868f
C1129 XFRONT.XFE_E.XN.n60 VSS 0.16803f
C1130 XFRONT.XFE_E.XN.n61 VSS 0.18011f
C1131 XFRONT.XFE_E.XN.n62 VSS 0.18011f
C1132 XFRONT.XFE_E.XN.n63 VSS 0.18011f
C1133 XFRONT.XFE_E.XN.n64 VSS 0.18011f
C1134 XFRONT.XFE_E.XN.n65 VSS 0.18011f
C1135 XFRONT.XFE_E.XN.n66 VSS 0.11679f
C1136 XFRONT.XFE_E.XN.n67 VSS 0.11679f
C1137 XFRONT.XFE_E.XN.n68 VSS 0.11653f
C1138 XFRONT.XFE_E.XN.n69 VSS 0.18011f
C1139 XFRONT.XFE_E.XN.n70 VSS 0.18011f
C1140 XFRONT.XFE_E.XN.n71 VSS 0.49868f
C1141 XFRONT.XFE_E.XN.n72 VSS 0.16803f
C1142 XFRONT.XFE_E.XN.n73 VSS 0.33968f
C1143 XFRONT.XFE_E.XN.n74 VSS 0.18011f
C1144 XFRONT.XFE_E.XN.n75 VSS 0.18011f
C1145 XFRONT.XFE_E.XN.n76 VSS 0.29791f
C1146 XFRONT.XFE_E.XN.n77 VSS 1.89723f
C1147 XFRONT.XFE_E.XN.n78 VSS 1.10618f
C1148 XFRONT.XFE_O.XN.t9 VSS 1.40085f
C1149 XFRONT.XFE_O.XN.t0 VSS 1.40913f
C1150 XFRONT.XFE_O.XN.t2 VSS 0.30031f
C1151 XFRONT.XFE_O.XN.t1 VSS 0.30031f
C1152 XFRONT.XFE_O.XN.n0 VSS 1.06449f
C1153 XFRONT.XFE_O.XN.n1 VSS 0.58512f
C1154 XFRONT.XFE_O.XN.t4 VSS 0.30031f
C1155 XFRONT.XFE_O.XN.t3 VSS 0.30031f
C1156 XFRONT.XFE_O.XN.n2 VSS 1.06449f
C1157 XFRONT.XFE_O.XN.n3 VSS 0.30545f
C1158 XFRONT.XFE_O.XN.t6 VSS 0.30031f
C1159 XFRONT.XFE_O.XN.t5 VSS 0.30031f
C1160 XFRONT.XFE_O.XN.n4 VSS 1.06449f
C1161 XFRONT.XFE_O.XN.n5 VSS 0.30545f
C1162 XFRONT.XFE_O.XN.t8 VSS 0.30031f
C1163 XFRONT.XFE_O.XN.t7 VSS 0.30031f
C1164 XFRONT.XFE_O.XN.n6 VSS 1.06449f
C1165 XFRONT.XFE_O.XN.n7 VSS 0.24533f
C1166 XFRONT.XFE_O.XN.n8 VSS 1.66511f
C1167 XFRONT.XFE_O.XN.n9 VSS 0.32954f
C1168 XFRONT.XFE_O.XN.n10 VSS 0.16803f
C1169 XFRONT.XFE_O.XN.n11 VSS 0.18011f
C1170 XFRONT.XFE_O.XN.n12 VSS 0.18011f
C1171 XFRONT.XFE_O.XN.n13 VSS 0.17033f
C1172 XFRONT.XFE_O.XN.n14 VSS 0.3775f
C1173 XFRONT.XFE_O.XN.n15 VSS 2.16471f
C1174 XFRONT.XFE_O.XN.n16 VSS 0.9973f
C1175 XFRONT.XFE_O.XN.n17 VSS 1.42665f
C1176 XFRONT.XFE_O.XN.t29 VSS 1.43937f
C1177 XFRONT.XFE_O.XN.t28 VSS 0.33222f
C1178 XFRONT.XFE_O.XN.t27 VSS 0.33222f
C1179 XFRONT.XFE_O.XN.n18 VSS 1.05664f
C1180 XFRONT.XFE_O.XN.n19 VSS 0.59551f
C1181 XFRONT.XFE_O.XN.t26 VSS 0.33222f
C1182 XFRONT.XFE_O.XN.t25 VSS 0.33222f
C1183 XFRONT.XFE_O.XN.n20 VSS 1.05664f
C1184 XFRONT.XFE_O.XN.n21 VSS 0.31329f
C1185 XFRONT.XFE_O.XN.t24 VSS 0.33222f
C1186 XFRONT.XFE_O.XN.t23 VSS 0.33222f
C1187 XFRONT.XFE_O.XN.n22 VSS 1.05664f
C1188 XFRONT.XFE_O.XN.n23 VSS 0.25318f
C1189 XFRONT.XFE_O.XN.t18 VSS 1.43937f
C1190 XFRONT.XFE_O.XN.t20 VSS 0.33222f
C1191 XFRONT.XFE_O.XN.t19 VSS 0.33222f
C1192 XFRONT.XFE_O.XN.n24 VSS 1.05664f
C1193 XFRONT.XFE_O.XN.n25 VSS 0.59551f
C1194 XFRONT.XFE_O.XN.t22 VSS 0.33222f
C1195 XFRONT.XFE_O.XN.t21 VSS 0.33222f
C1196 XFRONT.XFE_O.XN.n26 VSS 1.05664f
C1197 XFRONT.XFE_O.XN.n27 VSS 0.25318f
C1198 XFRONT.XFE_O.XN.n28 VSS 0.85518f
C1199 XFRONT.XFE_O.XN.n29 VSS 1.72642f
C1200 XFRONT.XFE_O.XN.t31 VSS 1.48871f
C1201 XFRONT.XFE_O.XN.t30 VSS 1.47912f
C1202 XFRONT.XFE_O.XN.n30 VSS 2.31351f
C1203 XFRONT.XFE_O.XN.n31 VSS 2.80885f
C1204 XFRONT.XFE_O.XN.t17 VSS 0.30288f
C1205 XFRONT.XFE_O.XN.t16 VSS 0.30031f
C1206 XFRONT.XFE_O.XN.n32 VSS 1.07282f
C1207 XFRONT.XFE_O.XN.t15 VSS 0.30031f
C1208 XFRONT.XFE_O.XN.t14 VSS 0.30031f
C1209 XFRONT.XFE_O.XN.n33 VSS 1.06449f
C1210 XFRONT.XFE_O.XN.t11 VSS 0.30031f
C1211 XFRONT.XFE_O.XN.t10 VSS 0.30289f
C1212 XFRONT.XFE_O.XN.n34 VSS 1.07282f
C1213 XFRONT.XFE_O.XN.t13 VSS 0.30031f
C1214 XFRONT.XFE_O.XN.t12 VSS 0.30031f
C1215 XFRONT.XFE_O.XN.n35 VSS 1.06449f
C1216 XFRONT.XFE_O.XN.n36 VSS 0.53944f
C1217 XFRONT.XFE_O.XN.n37 VSS 1.44722f
C1218 XFRONT.XFE_O.XN.n38 VSS 1.69004f
C1219 XFRONT.XFE_O.XN.n39 VSS 1.44329f
C1220 XFRONT.XFE_O.XN.n40 VSS 3.21788f
C1221 XFRONT.XFE_O.XN.n41 VSS 0.24424f
C1222 XFRONT.XFE_O.XN.n42 VSS 0.25216f
C1223 XFRONT.XFE_O.XN.n43 VSS 0.25216f
C1224 XFRONT.XFE_O.XN.n44 VSS 0.18011f
C1225 XFRONT.XFE_O.XN.n45 VSS 0.49868f
C1226 XFRONT.XFE_O.XN.n46 VSS 0.16803f
C1227 XFRONT.XFE_O.XN.n47 VSS 0.33968f
C1228 XFRONT.XFE_O.XN.n48 VSS 0.18011f
C1229 XFRONT.XFE_O.XN.n49 VSS 0.11653f
C1230 XFRONT.XFE_O.XN.n50 VSS 0.11679f
C1231 XFRONT.XFE_O.XN.n51 VSS 0.11679f
C1232 XFRONT.XFE_O.XN.n52 VSS 0.11679f
C1233 XFRONT.XFE_O.XN.n53 VSS 0.11679f
C1234 XFRONT.XFE_O.XN.n54 VSS 0.18011f
C1235 XFRONT.XFE_O.XN.n55 VSS 0.25242f
C1236 XFRONT.XFE_O.XN.n56 VSS 0.25242f
C1237 XFRONT.XFE_O.XN.n57 VSS 0.25242f
C1238 XFRONT.XFE_O.XN.n58 VSS 0.25242f
C1239 XFRONT.XFE_O.XN.n59 VSS 0.25242f
C1240 XFRONT.XFE_O.XN.n60 VSS 0.49868f
C1241 XFRONT.XFE_O.XN.n61 VSS 0.16803f
C1242 XFRONT.XFE_O.XN.n62 VSS 0.33994f
C1243 XFRONT.XFE_O.XN.n63 VSS 0.18011f
C1244 XFRONT.XFE_O.XN.n64 VSS 0.18011f
C1245 XFRONT.XFE_O.XN.n65 VSS 0.18011f
C1246 XFRONT.XFE_O.XN.n66 VSS 0.18011f
C1247 XFRONT.XFE_O.XN.n67 VSS 0.18011f
C1248 XFRONT.XFE_O.XN.n68 VSS 0.18011f
C1249 XFRONT.XFE_O.XN.n69 VSS 0.18011f
C1250 XFRONT.XFE_O.XN.n70 VSS 0.29791f
C1251 XFRONT.XFE_O.XN.n71 VSS 1.89723f
C1252 XFRONT.XFE_O.XN.n72 VSS 1.11528f
C1253 XFRONT.XFE_O.XN.n73 VSS 0.17033f
C1254 XFRONT.XFE_O.XN.n74 VSS 0.16803f
C1255 XFRONT.XFE_O.XN.n75 VSS 0.18011f
C1256 XFRONT.XFE_O.XN.n76 VSS 0.18011f
C1257 XFRONT.XFE_O.XN.n77 VSS 0.32954f
C1258 XFRONT.XFE_O.XN.n78 VSS 1.2398f
C1259 XFRONT.XFE_O.XN.n79 VSS 1.90891f
C1260 XFRONT.XFE_O.XP.n0 VSS 0.33737f
C1261 XFRONT.XFE_O.XP.n1 VSS 0.16675f
C1262 XFRONT.XFE_O.XP.n2 VSS 0.17874f
C1263 XFRONT.XFE_O.XP.n3 VSS 0.17874f
C1264 XFRONT.XFE_O.XP.n4 VSS 0.16893f
C1265 XFRONT.XFE_O.XP.n5 VSS 1.42089f
C1266 XFRONT.XFE_O.XP.n6 VSS 0.24239f
C1267 XFRONT.XFE_O.XP.n7 VSS 0.25025f
C1268 XFRONT.XFE_O.XP.n8 VSS 0.25025f
C1269 XFRONT.XFE_O.XP.n9 VSS 0.17874f
C1270 XFRONT.XFE_O.XP.n10 VSS 0.4949f
C1271 XFRONT.XFE_O.XP.n11 VSS 0.16675f
C1272 XFRONT.XFE_O.XP.n12 VSS 0.3371f
C1273 XFRONT.XFE_O.XP.n13 VSS 0.17874f
C1274 XFRONT.XFE_O.XP.n14 VSS 0.11565f
C1275 XFRONT.XFE_O.XP.n15 VSS 0.11591f
C1276 XFRONT.XFE_O.XP.n16 VSS 0.11591f
C1277 XFRONT.XFE_O.XP.n17 VSS 0.11591f
C1278 XFRONT.XFE_O.XP.n18 VSS 0.11591f
C1279 XFRONT.XFE_O.XP.n19 VSS 0.17874f
C1280 XFRONT.XFE_O.XP.n20 VSS 0.25051f
C1281 XFRONT.XFE_O.XP.n21 VSS 0.25051f
C1282 XFRONT.XFE_O.XP.n22 VSS 0.25051f
C1283 XFRONT.XFE_O.XP.n23 VSS 0.25051f
C1284 XFRONT.XFE_O.XP.n24 VSS 0.25051f
C1285 XFRONT.XFE_O.XP.n25 VSS 0.4949f
C1286 XFRONT.XFE_O.XP.n26 VSS 0.16675f
C1287 XFRONT.XFE_O.XP.n27 VSS 0.33737f
C1288 XFRONT.XFE_O.XP.n28 VSS 0.17874f
C1289 XFRONT.XFE_O.XP.n29 VSS 0.17874f
C1290 XFRONT.XFE_O.XP.n30 VSS 0.17874f
C1291 XFRONT.XFE_O.XP.n31 VSS 0.17874f
C1292 XFRONT.XFE_O.XP.n32 VSS 0.17874f
C1293 XFRONT.XFE_O.XP.n33 VSS 0.17874f
C1294 XFRONT.XFE_O.XP.n34 VSS 0.17874f
C1295 XFRONT.XFE_O.XP.n35 VSS 0.29566f
C1296 XFRONT.XFE_O.XP.n36 VSS 1.795f
C1297 XFRONT.XFE_O.XP.n37 VSS 3.10172f
C1298 XFRONT.XFE_O.XP.n38 VSS 1.47542f
C1299 XFRONT.XFE_O.XP.n39 VSS 3.45737f
C1300 XFRONT.XFE_O.XP.t15 VSS 1.39919f
C1301 XFRONT.XFE_O.XP.t10 VSS 0.29876f
C1302 XFRONT.XFE_O.XP.t26 VSS 0.29876f
C1303 XFRONT.XFE_O.XP.n40 VSS 1.05643f
C1304 XFRONT.XFE_O.XP.n41 VSS 0.58069f
C1305 XFRONT.XFE_O.XP.t9 VSS 0.29876f
C1306 XFRONT.XFE_O.XP.t14 VSS 0.29876f
C1307 XFRONT.XFE_O.XP.n42 VSS 1.05643f
C1308 XFRONT.XFE_O.XP.n43 VSS 0.24348f
C1309 XFRONT.XFE_O.XP.t11 VSS 1.3992f
C1310 XFRONT.XFE_O.XP.t13 VSS 0.29876f
C1311 XFRONT.XFE_O.XP.t12 VSS 0.29876f
C1312 XFRONT.XFE_O.XP.n44 VSS 1.05643f
C1313 XFRONT.XFE_O.XP.n45 VSS 0.52103f
C1314 XFRONT.XFE_O.XP.n46 VSS 1.37228f
C1315 XFRONT.XFE_O.XP.n47 VSS 2.05638f
C1316 XFRONT.XFE_O.XP.t27 VSS 1.47329f
C1317 XFRONT.XFE_O.XP.t28 VSS 1.47571f
C1318 XFRONT.XFE_O.XP.n48 VSS 2.36091f
C1319 XFRONT.XFE_O.XP.n49 VSS 2.92298f
C1320 XFRONT.XFE_O.XP.t0 VSS 1.43044f
C1321 XFRONT.XFE_O.XP.t1 VSS 0.33163f
C1322 XFRONT.XFE_O.XP.t2 VSS 0.33163f
C1323 XFRONT.XFE_O.XP.n50 VSS 1.04864f
C1324 XFRONT.XFE_O.XP.n51 VSS 0.591f
C1325 XFRONT.XFE_O.XP.t6 VSS 0.33163f
C1326 XFRONT.XFE_O.XP.t7 VSS 0.33163f
C1327 XFRONT.XFE_O.XP.n52 VSS 1.04864f
C1328 XFRONT.XFE_O.XP.n53 VSS 0.31092f
C1329 XFRONT.XFE_O.XP.t8 VSS 0.33163f
C1330 XFRONT.XFE_O.XP.t3 VSS 0.33163f
C1331 XFRONT.XFE_O.XP.n54 VSS 1.04864f
C1332 XFRONT.XFE_O.XP.n55 VSS 0.25126f
C1333 XFRONT.XFE_O.XP.t31 VSS 1.43044f
C1334 XFRONT.XFE_O.XP.t29 VSS 0.33163f
C1335 XFRONT.XFE_O.XP.t30 VSS 0.33163f
C1336 XFRONT.XFE_O.XP.n56 VSS 1.04864f
C1337 XFRONT.XFE_O.XP.n57 VSS 0.591f
C1338 XFRONT.XFE_O.XP.t4 VSS 0.33163f
C1339 XFRONT.XFE_O.XP.t5 VSS 0.33163f
C1340 XFRONT.XFE_O.XP.n58 VSS 1.04864f
C1341 XFRONT.XFE_O.XP.n59 VSS 0.25126f
C1342 XFRONT.XFE_O.XP.n60 VSS 0.78552f
C1343 XFRONT.XFE_O.XP.n61 VSS 1.62307f
C1344 XFRONT.XFE_O.XP.n62 VSS 0.95385f
C1345 XFRONT.XFE_O.XP.n63 VSS 1.25315f
C1346 XFRONT.XFE_O.XP.n64 VSS 0.16904f
C1347 XFRONT.XFE_O.XP.n65 VSS 0.16675f
C1348 XFRONT.XFE_O.XP.n66 VSS 0.17874f
C1349 XFRONT.XFE_O.XP.n67 VSS 0.17874f
C1350 XFRONT.XFE_O.XP.n68 VSS 0.32704f
C1351 XFRONT.XFE_O.XP.n69 VSS 0.42062f
C1352 XFRONT.XFE_O.XP.n70 VSS 0.87173f
C1353 XFRONT.XFE_O.XP.t25 VSS 1.3992f
C1354 XFRONT.XFE_O.XP.t24 VSS 0.29876f
C1355 XFRONT.XFE_O.XP.t23 VSS 0.29876f
C1356 XFRONT.XFE_O.XP.n71 VSS 1.05643f
C1357 XFRONT.XFE_O.XP.n72 VSS 0.58069f
C1358 XFRONT.XFE_O.XP.t22 VSS 0.29876f
C1359 XFRONT.XFE_O.XP.t21 VSS 0.29876f
C1360 XFRONT.XFE_O.XP.n73 VSS 1.05643f
C1361 XFRONT.XFE_O.XP.n74 VSS 0.30313f
C1362 XFRONT.XFE_O.XP.t20 VSS 0.29876f
C1363 XFRONT.XFE_O.XP.t19 VSS 0.29876f
C1364 XFRONT.XFE_O.XP.n75 VSS 1.05643f
C1365 XFRONT.XFE_O.XP.n76 VSS 0.30313f
C1366 XFRONT.XFE_O.XP.t18 VSS 0.29876f
C1367 XFRONT.XFE_O.XP.t17 VSS 0.29876f
C1368 XFRONT.XFE_O.XP.n77 VSS 1.05643f
C1369 XFRONT.XFE_O.XP.n78 VSS 0.28822f
C1370 XFRONT.XFE_O.XP.t16 VSS 1.38791f
C1371 XFRONT.XFE_O.XP.n79 VSS 1.55413f
C1372 XFRONT.XFE_O.XP.n80 VSS 1.56891f
C1373 XFRONT.XFE_E.HB.n0 VSS 0.2398f
C1374 XFRONT.XFE_E.HB.n1 VSS 0.11853f
C1375 XFRONT.XFE_E.HB.n2 VSS 0.12705f
C1376 XFRONT.XFE_E.HB.n3 VSS 0.12705f
C1377 XFRONT.XFE_E.HB.n4 VSS 0.12008f
C1378 XFRONT.XFE_E.HB.n5 VSS 0.46053f
C1379 XFRONT.XFE_E.HB.n6 VSS 0.11853f
C1380 XFRONT.XFE_E.HB.n7 VSS 0.12705f
C1381 XFRONT.XFE_E.HB.n8 VSS 0.12008f
C1382 XFRONT.XFE_E.HB.n9 VSS 0.67097f
C1383 XFRONT.XFE_E.HB.n10 VSS 0.12015f
C1384 XFRONT.XFE_E.HB.n11 VSS 0.11853f
C1385 XFRONT.XFE_E.HB.n12 VSS 0.12705f
C1386 XFRONT.XFE_E.HB.n13 VSS 0.12705f
C1387 XFRONT.XFE_E.HB.n14 VSS 0.23246f
C1388 XFRONT.XFE_E.HB.n15 VSS 0.2663f
C1389 XFRONT.XFE_E.HB.n16 VSS 1.55603f
C1390 XFRONT.XFE_E.HB.t10 VSS 0.995f
C1391 XFRONT.XFE_E.HB.t9 VSS 0.21453f
C1392 XFRONT.XFE_E.HB.t8 VSS 0.21453f
C1393 XFRONT.XFE_E.HB.n17 VSS 0.74539f
C1394 XFRONT.XFE_E.HB.n18 VSS 0.37768f
C1395 XFRONT.XFE_E.HB.t3 VSS 0.99499f
C1396 XFRONT.XFE_E.HB.t5 VSS 0.21453f
C1397 XFRONT.XFE_E.HB.t4 VSS 0.21453f
C1398 XFRONT.XFE_E.HB.n19 VSS 0.74539f
C1399 XFRONT.XFE_E.HB.n20 VSS 0.42009f
C1400 XFRONT.XFE_E.HB.t7 VSS 0.21453f
C1401 XFRONT.XFE_E.HB.t6 VSS 0.21453f
C1402 XFRONT.XFE_E.HB.n21 VSS 0.74539f
C1403 XFRONT.XFE_E.HB.n22 VSS 0.1786f
C1404 XFRONT.XFE_E.HB.n23 VSS 0.17978f
C1405 XFRONT.XFE_E.HB.n24 VSS 0.85854f
C1406 XFRONT.XFE_E.HB.t15 VSS 1.04006f
C1407 XFRONT.XFE_E.HB.t12 VSS 1.04186f
C1408 XFRONT.XFE_E.HB.t14 VSS 0.26148f
C1409 XFRONT.XFE_E.HB.t13 VSS 0.26148f
C1410 XFRONT.XFE_E.HB.n25 VSS 0.75093f
C1411 XFRONT.XFE_E.HB.n26 VSS 0.37035f
C1412 XFRONT.XFE_E.HB.n27 VSS 0.88409f
C1413 XFRONT.XFE_E.HB.n28 VSS 0.92912f
C1414 XFRONT.XFE_E.HB.t16 VSS 1.31404f
C1415 XFRONT.XFE_E.HB.n29 VSS 0.72746f
C1416 XFRONT.XFE_E.HB.t2 VSS 1.10226f
C1417 XFRONT.XFE_E.HB.t0 VSS 0.31856f
C1418 XFRONT.XFE_E.HB.t1 VSS 0.31856f
C1419 XFRONT.XFE_E.HB.n30 VSS 0.75093f
C1420 XFRONT.XFE_E.HB.n31 VSS 0.33855f
C1421 XFRONT.XFE_E.HB.t11 VSS 1.09781f
C1422 XFRONT.XFE_E.HB.n32 VSS 1.68299f
C1423 XFRONT.XFE_E.HB.n33 VSS 3.98342f
C1424 XFRONT.XFE_E.HB.n34 VSS 3.12293f
C1425 XFRONT.XFE_E.H.n0 VSS 0.11342f
C1426 XFRONT.XFE_E.H.n1 VSS 0.11189f
C1427 XFRONT.XFE_E.H.n2 VSS 0.11993f
C1428 XFRONT.XFE_E.H.n3 VSS 0.11993f
C1429 XFRONT.XFE_E.H.n4 VSS 0.21944f
C1430 XFRONT.XFE_E.H.n5 VSS 0.22162f
C1431 XFRONT.XFE_E.H.n6 VSS 0.21944f
C1432 XFRONT.XFE_E.H.n7 VSS 0.11189f
C1433 XFRONT.XFE_E.H.n8 VSS 0.11993f
C1434 XFRONT.XFE_E.H.n9 VSS 0.11993f
C1435 XFRONT.XFE_E.H.n10 VSS 0.11342f
C1436 XFRONT.XFE_E.H.n11 VSS 0.44107f
C1437 XFRONT.XFE_E.H.n12 VSS 3.43312f
C1438 XFRONT.XFE_E.H.t12 VSS 1.04796f
C1439 XFRONT.XFE_E.H.t15 VSS 1.04841f
C1440 XFRONT.XFE_E.H.t13 VSS 0.31176f
C1441 XFRONT.XFE_E.H.t14 VSS 0.31176f
C1442 XFRONT.XFE_E.H.n13 VSS 0.70885f
C1443 XFRONT.XFE_E.H.n14 VSS 0.3496f
C1444 XFRONT.XFE_E.H.n15 VSS 1.60381f
C1445 XFRONT.XFE_E.H.n16 VSS 3.91167f
C1446 XFRONT.XFE_E.H.t0 VSS 1.22975f
C1447 XFRONT.XFE_E.H.n17 VSS 0.73537f
C1448 XFRONT.XFE_E.H.t16 VSS 0.99312f
C1449 XFRONT.XFE_E.H.t1 VSS 0.99928f
C1450 XFRONT.XFE_E.H.t2 VSS 0.26026f
C1451 XFRONT.XFE_E.H.t3 VSS 0.26026f
C1452 XFRONT.XFE_E.H.n18 VSS 0.70885f
C1453 XFRONT.XFE_E.H.n19 VSS 0.3496f
C1454 XFRONT.XFE_E.H.n20 VSS 0.87696f
C1455 XFRONT.XFE_E.H.n21 VSS 0.88918f
C1456 XFRONT.XFE_E.H.t11 VSS 0.94461f
C1457 XFRONT.XFE_E.H.t10 VSS 0.20773f
C1458 XFRONT.XFE_E.H.t9 VSS 0.20773f
C1459 XFRONT.XFE_E.H.n22 VSS 0.70362f
C1460 XFRONT.XFE_E.H.n23 VSS 0.35652f
C1461 XFRONT.XFE_E.H.t4 VSS 0.94461f
C1462 XFRONT.XFE_E.H.t6 VSS 0.20773f
C1463 XFRONT.XFE_E.H.t5 VSS 0.20773f
C1464 XFRONT.XFE_E.H.n24 VSS 0.70362f
C1465 XFRONT.XFE_E.H.n25 VSS 0.39655f
C1466 XFRONT.XFE_E.H.t8 VSS 0.20773f
C1467 XFRONT.XFE_E.H.t7 VSS 0.20773f
C1468 XFRONT.XFE_E.H.n26 VSS 0.70362f
C1469 XFRONT.XFE_E.H.n27 VSS 0.1686f
C1470 XFRONT.XFE_E.H.n28 VSS 0.2121f
C1471 XFRONT.XFE_E.H.n29 VSS 0.7741f
C1472 XFRONT.XFE_E.H.n30 VSS 0.11189f
C1473 XFRONT.XFE_E.H.n31 VSS 0.11993f
C1474 XFRONT.XFE_E.H.n32 VSS 0.11335f
C1475 XFRONT.XFE_E.H.n33 VSS 0.64427f
C1476 XFRONT.XFE_E.H.n34 VSS 1.07962f
C1477 XFRONT.XFE_O.H.n0 VSS 0.11342f
C1478 XFRONT.XFE_O.H.n1 VSS 0.11189f
C1479 XFRONT.XFE_O.H.n2 VSS 0.11993f
C1480 XFRONT.XFE_O.H.n3 VSS 0.11993f
C1481 XFRONT.XFE_O.H.n4 VSS 0.21944f
C1482 XFRONT.XFE_O.H.n5 VSS 0.44107f
C1483 XFRONT.XFE_O.H.n6 VSS 3.43312f
C1484 XFRONT.XFE_O.H.t7 VSS 1.04841f
C1485 XFRONT.XFE_O.H.t0 VSS 0.31176f
C1486 XFRONT.XFE_O.H.t1 VSS 0.31176f
C1487 XFRONT.XFE_O.H.n7 VSS 0.70885f
C1488 XFRONT.XFE_O.H.n8 VSS 0.3496f
C1489 XFRONT.XFE_O.H.t8 VSS 1.04796f
C1490 XFRONT.XFE_O.H.n9 VSS 1.60381f
C1491 XFRONT.XFE_O.H.n10 VSS 3.91167f
C1492 XFRONT.XFE_O.H.t6 VSS 1.22975f
C1493 XFRONT.XFE_O.H.n11 VSS 0.73537f
C1494 XFRONT.XFE_O.H.t5 VSS 0.99928f
C1495 XFRONT.XFE_O.H.t4 VSS 0.26026f
C1496 XFRONT.XFE_O.H.t3 VSS 0.26026f
C1497 XFRONT.XFE_O.H.n12 VSS 0.70885f
C1498 XFRONT.XFE_O.H.n13 VSS 0.3496f
C1499 XFRONT.XFE_O.H.t2 VSS 0.99312f
C1500 XFRONT.XFE_O.H.n14 VSS 0.87696f
C1501 XFRONT.XFE_O.H.n15 VSS 0.88918f
C1502 XFRONT.XFE_O.H.t16 VSS 0.94461f
C1503 XFRONT.XFE_O.H.t15 VSS 0.20773f
C1504 XFRONT.XFE_O.H.t14 VSS 0.20773f
C1505 XFRONT.XFE_O.H.n16 VSS 0.70362f
C1506 XFRONT.XFE_O.H.n17 VSS 0.39655f
C1507 XFRONT.XFE_O.H.t13 VSS 0.20773f
C1508 XFRONT.XFE_O.H.t12 VSS 0.20773f
C1509 XFRONT.XFE_O.H.n18 VSS 0.70362f
C1510 XFRONT.XFE_O.H.n19 VSS 0.1686f
C1511 XFRONT.XFE_O.H.t9 VSS 0.94461f
C1512 XFRONT.XFE_O.H.t11 VSS 0.20773f
C1513 XFRONT.XFE_O.H.t10 VSS 0.20773f
C1514 XFRONT.XFE_O.H.n20 VSS 0.70362f
C1515 XFRONT.XFE_O.H.n21 VSS 0.35652f
C1516 XFRONT.XFE_O.H.n22 VSS 0.2121f
C1517 XFRONT.XFE_O.H.n23 VSS 0.7741f
C1518 XFRONT.XFE_O.H.n24 VSS 0.11189f
C1519 XFRONT.XFE_O.H.n25 VSS 0.11993f
C1520 XFRONT.XFE_O.H.n26 VSS 0.11335f
C1521 XFRONT.XFE_O.H.n27 VSS 0.64427f
C1522 XFRONT.XFE_O.H.n28 VSS 1.08568f
C1523 XFRONT.XFE_O.H.n29 VSS 0.21944f
C1524 XFRONT.XFE_O.H.n30 VSS 0.11189f
C1525 XFRONT.XFE_O.H.n31 VSS 0.11993f
C1526 XFRONT.XFE_O.H.n32 VSS 0.11993f
C1527 XFRONT.XFE_O.H.n33 VSS 0.11342f
C1528 XFRONT.XFE_O.H.n34 VSS 0.22097f
C1529 XFRONT.XFE_O.H.n35 VSS 0.30698f
C1530 XFRONT.XFE_O.HB.n0 VSS 0.11853f
C1531 XFRONT.XFE_O.HB.n1 VSS 0.12705f
C1532 XFRONT.XFE_O.HB.n2 VSS 0.12008f
C1533 XFRONT.XFE_O.HB.n3 VSS 0.67097f
C1534 XFRONT.XFE_O.HB.n4 VSS 0.23246f
C1535 XFRONT.XFE_O.HB.n5 VSS 0.11853f
C1536 XFRONT.XFE_O.HB.n6 VSS 0.12705f
C1537 XFRONT.XFE_O.HB.n7 VSS 0.12705f
C1538 XFRONT.XFE_O.HB.n8 VSS 0.12015f
C1539 XFRONT.XFE_O.HB.n9 VSS 0.2663f
C1540 XFRONT.XFE_O.HB.n10 VSS 1.55603f
C1541 XFRONT.XFE_O.HB.t7 VSS 0.99499f
C1542 XFRONT.XFE_O.HB.t6 VSS 0.21453f
C1543 XFRONT.XFE_O.HB.t5 VSS 0.21453f
C1544 XFRONT.XFE_O.HB.n11 VSS 0.74539f
C1545 XFRONT.XFE_O.HB.n12 VSS 0.42009f
C1546 XFRONT.XFE_O.HB.t4 VSS 0.21453f
C1547 XFRONT.XFE_O.HB.t3 VSS 0.21453f
C1548 XFRONT.XFE_O.HB.n13 VSS 0.74539f
C1549 XFRONT.XFE_O.HB.n14 VSS 0.1786f
C1550 XFRONT.XFE_O.HB.t0 VSS 0.995f
C1551 XFRONT.XFE_O.HB.t2 VSS 0.21453f
C1552 XFRONT.XFE_O.HB.t1 VSS 0.21453f
C1553 XFRONT.XFE_O.HB.n15 VSS 0.74539f
C1554 XFRONT.XFE_O.HB.n16 VSS 0.37768f
C1555 XFRONT.XFE_O.HB.n17 VSS 0.17978f
C1556 XFRONT.XFE_O.HB.n18 VSS 0.85854f
C1557 XFRONT.XFE_O.HB.t11 VSS 1.04186f
C1558 XFRONT.XFE_O.HB.t12 VSS 0.26148f
C1559 XFRONT.XFE_O.HB.t9 VSS 0.26148f
C1560 XFRONT.XFE_O.HB.n19 VSS 0.75092f
C1561 XFRONT.XFE_O.HB.n20 VSS 0.37035f
C1562 XFRONT.XFE_O.HB.t10 VSS 1.04006f
C1563 XFRONT.XFE_O.HB.n21 VSS 0.88409f
C1564 XFRONT.XFE_O.HB.n22 VSS 0.92912f
C1565 XFRONT.XFE_O.HB.t13 VSS 1.31404f
C1566 XFRONT.XFE_O.HB.n23 VSS 0.72746f
C1567 XFRONT.XFE_O.HB.t14 VSS 1.09781f
C1568 XFRONT.XFE_O.HB.t8 VSS 1.10226f
C1569 XFRONT.XFE_O.HB.t15 VSS 0.31856f
C1570 XFRONT.XFE_O.HB.t16 VSS 0.31856f
C1571 XFRONT.XFE_O.HB.n24 VSS 0.75092f
C1572 XFRONT.XFE_O.HB.n25 VSS 0.33855f
C1573 XFRONT.XFE_O.HB.n26 VSS 1.68299f
C1574 XFRONT.XFE_O.HB.n27 VSS 3.98342f
C1575 XFRONT.XFE_O.HB.n28 VSS 3.12935f
C1576 XFRONT.XFE_O.HB.n29 VSS 0.2398f
C1577 XFRONT.XFE_O.HB.n30 VSS 0.11853f
C1578 XFRONT.XFE_O.HB.n31 VSS 0.12705f
C1579 XFRONT.XFE_O.HB.n32 VSS 0.12705f
C1580 XFRONT.XFE_O.HB.n33 VSS 0.12008f
C1581 XFRONT.XFE_O.HB.n34 VSS 0.4592f
C1582 XFRONT.XFE_O.HB.n35 VSS 0.70771f
C1583 XFRONT.XFE_E.NIN.t20 VSS 1.60137f
C1584 XFRONT.XFE_E.NIN.t19 VSS 0.29711f
C1585 XFRONT.XFE_E.NIN.t18 VSS 0.29711f
C1586 XFRONT.XFE_E.NIN.n0 VSS 1.24724f
C1587 XFRONT.XFE_E.NIN.n1 VSS 0.63197f
C1588 XFRONT.XFE_E.NIN.t13 VSS 1.60138f
C1589 XFRONT.XFE_E.NIN.t15 VSS 0.29711f
C1590 XFRONT.XFE_E.NIN.t14 VSS 0.29711f
C1591 XFRONT.XFE_E.NIN.n2 VSS 1.24724f
C1592 XFRONT.XFE_E.NIN.n3 VSS 0.70293f
C1593 XFRONT.XFE_E.NIN.t17 VSS 0.29711f
C1594 XFRONT.XFE_E.NIN.t16 VSS 0.29711f
C1595 XFRONT.XFE_E.NIN.n4 VSS 1.24724f
C1596 XFRONT.XFE_E.NIN.n5 VSS 0.29885f
C1597 XFRONT.XFE_E.NIN.n6 VSS 0.9909f
C1598 XFRONT.XFE_E.NIN.t0 VSS 0.37276f
C1599 XFRONT.XFE_E.NIN.t10 VSS 0.36932f
C1600 XFRONT.XFE_E.NIN.n7 VSS 1.25728f
C1601 XFRONT.XFE_E.NIN.t11 VSS 0.36932f
C1602 XFRONT.XFE_E.NIN.t12 VSS 0.36932f
C1603 XFRONT.XFE_E.NIN.n8 VSS 1.24724f
C1604 XFRONT.XFE_E.NIN.n9 VSS 0.65507f
C1605 XFRONT.XFE_E.NIN.t7 VSS 0.36932f
C1606 XFRONT.XFE_E.NIN.t8 VSS 0.36932f
C1607 XFRONT.XFE_E.NIN.n10 VSS 1.24724f
C1608 XFRONT.XFE_E.NIN.n11 VSS 0.36981f
C1609 XFRONT.XFE_E.NIN.t9 VSS 0.36932f
C1610 XFRONT.XFE_E.NIN.t21 VSS 0.36932f
C1611 XFRONT.XFE_E.NIN.n12 VSS 1.24724f
C1612 XFRONT.XFE_E.NIN.t5 VSS 0.36932f
C1613 XFRONT.XFE_E.NIN.t6 VSS 0.37276f
C1614 XFRONT.XFE_E.NIN.n13 VSS 1.25728f
C1615 XFRONT.XFE_E.NIN.t22 VSS 0.36932f
C1616 XFRONT.XFE_E.NIN.t23 VSS 0.36932f
C1617 XFRONT.XFE_E.NIN.n14 VSS 1.24724f
C1618 XFRONT.XFE_E.NIN.n15 VSS 0.65507f
C1619 XFRONT.XFE_E.NIN.n16 VSS 1.00904f
C1620 XFRONT.XFE_E.NIN.t4 VSS 1.67404f
C1621 XFRONT.XFE_E.NIN.t1 VSS 1.67828f
C1622 XFRONT.XFE_E.NIN.t3 VSS 0.37249f
C1623 XFRONT.XFE_E.NIN.t2 VSS 0.37249f
C1624 XFRONT.XFE_E.NIN.n17 VSS 1.25651f
C1625 XFRONT.XFE_E.NIN.n18 VSS 0.61971f
C1626 XFRONT.XFE_E.NIN.n19 VSS 3.4549f
C1627 XFRONT.XFE_E.NIN.n20 VSS 4.90308f
C1628 XFRONT.XFE_E.NIP.t4 VSS 0.37035f
C1629 XFRONT.XFE_E.NIP.t5 VSS 0.36688f
C1630 XFRONT.XFE_E.NIP.n0 VSS 1.23967f
C1631 XFRONT.XFE_E.NIP.t13 VSS 0.36688f
C1632 XFRONT.XFE_E.NIP.t14 VSS 0.36688f
C1633 XFRONT.XFE_E.NIP.n1 VSS 1.22977f
C1634 XFRONT.XFE_E.NIP.n2 VSS 0.6459f
C1635 XFRONT.XFE_E.NIP.t15 VSS 0.36688f
C1636 XFRONT.XFE_E.NIP.t10 VSS 0.36688f
C1637 XFRONT.XFE_E.NIP.n3 VSS 1.22977f
C1638 XFRONT.XFE_E.NIP.n4 VSS 0.36463f
C1639 XFRONT.XFE_E.NIP.t11 VSS 0.36688f
C1640 XFRONT.XFE_E.NIP.t12 VSS 0.36688f
C1641 XFRONT.XFE_E.NIP.n5 VSS 1.22977f
C1642 XFRONT.XFE_E.NIP.t2 VSS 0.36688f
C1643 XFRONT.XFE_E.NIP.t3 VSS 0.37035f
C1644 XFRONT.XFE_E.NIP.n6 VSS 1.23967f
C1645 XFRONT.XFE_E.NIP.t0 VSS 0.36688f
C1646 XFRONT.XFE_E.NIP.t1 VSS 0.36688f
C1647 XFRONT.XFE_E.NIP.n7 VSS 1.22977f
C1648 XFRONT.XFE_E.NIP.n8 VSS 0.6459f
C1649 XFRONT.XFE_E.NIP.n9 VSS 0.93638f
C1650 XFRONT.XFE_E.NIP.t23 VSS 1.57991f
C1651 XFRONT.XFE_E.NIP.t22 VSS 0.2939f
C1652 XFRONT.XFE_E.NIP.t21 VSS 0.2939f
C1653 XFRONT.XFE_E.NIP.n10 VSS 1.22977f
C1654 XFRONT.XFE_E.NIP.n11 VSS 0.62312f
C1655 XFRONT.XFE_E.NIP.t16 VSS 1.57991f
C1656 XFRONT.XFE_E.NIP.t18 VSS 0.2939f
C1657 XFRONT.XFE_E.NIP.t17 VSS 0.2939f
C1658 XFRONT.XFE_E.NIP.n12 VSS 1.22977f
C1659 XFRONT.XFE_E.NIP.n13 VSS 0.69308f
C1660 XFRONT.XFE_E.NIP.t20 VSS 0.2939f
C1661 XFRONT.XFE_E.NIP.t19 VSS 0.2939f
C1662 XFRONT.XFE_E.NIP.n14 VSS 1.22977f
C1663 XFRONT.XFE_E.NIP.n15 VSS 0.29467f
C1664 XFRONT.XFE_E.NIP.n16 VSS 1.25236f
C1665 XFRONT.XFE_E.NIP.t9 VSS 1.65244f
C1666 XFRONT.XFE_E.NIP.t6 VSS 1.65659f
C1667 XFRONT.XFE_E.NIP.t8 VSS 0.36909f
C1668 XFRONT.XFE_E.NIP.t7 VSS 0.36909f
C1669 XFRONT.XFE_E.NIP.n17 VSS 1.23891f
C1670 XFRONT.XFE_E.NIP.n18 VSS 0.61102f
C1671 XFRONT.XFE_E.NIP.n19 VSS 3.48061f
C1672 XFRONT.XFE_E.NIP.n20 VSS 5.15681f
C1673 XFRONT.XFE_O.NIP.t20 VSS 1.57972f
C1674 XFRONT.XFE_O.NIP.t19 VSS 0.29371f
C1675 XFRONT.XFE_O.NIP.t18 VSS 0.29371f
C1676 XFRONT.XFE_O.NIP.n0 VSS 1.22977f
C1677 XFRONT.XFE_O.NIP.n1 VSS 0.69308f
C1678 XFRONT.XFE_O.NIP.t17 VSS 0.29371f
C1679 XFRONT.XFE_O.NIP.t16 VSS 0.29371f
C1680 XFRONT.XFE_O.NIP.n2 VSS 1.22977f
C1681 XFRONT.XFE_O.NIP.n3 VSS 0.29467f
C1682 XFRONT.XFE_O.NIP.t13 VSS 1.57973f
C1683 XFRONT.XFE_O.NIP.t15 VSS 0.29371f
C1684 XFRONT.XFE_O.NIP.t14 VSS 0.29371f
C1685 XFRONT.XFE_O.NIP.n4 VSS 1.22977f
C1686 XFRONT.XFE_O.NIP.n5 VSS 0.62312f
C1687 XFRONT.XFE_O.NIP.n6 VSS 1.25236f
C1688 XFRONT.XFE_O.NIP.t12 VSS 1.65659f
C1689 XFRONT.XFE_O.NIP.t11 VSS 0.36909f
C1690 XFRONT.XFE_O.NIP.t10 VSS 0.36909f
C1691 XFRONT.XFE_O.NIP.n7 VSS 1.23891f
C1692 XFRONT.XFE_O.NIP.n8 VSS 0.61102f
C1693 XFRONT.XFE_O.NIP.t9 VSS 1.65244f
C1694 XFRONT.XFE_O.NIP.n9 VSS 3.48061f
C1695 XFRONT.XFE_O.NIP.n10 VSS 5.1674f
C1696 XFRONT.XFE_O.NIP.t0 VSS 0.37035f
C1697 XFRONT.XFE_O.NIP.t1 VSS 0.36688f
C1698 XFRONT.XFE_O.NIP.n11 VSS 1.23967f
C1699 XFRONT.XFE_O.NIP.t2 VSS 0.36688f
C1700 XFRONT.XFE_O.NIP.t6 VSS 0.36688f
C1701 XFRONT.XFE_O.NIP.n12 VSS 1.22977f
C1702 XFRONT.XFE_O.NIP.n13 VSS 0.6459f
C1703 XFRONT.XFE_O.NIP.t7 VSS 0.36688f
C1704 XFRONT.XFE_O.NIP.t8 VSS 0.36688f
C1705 XFRONT.XFE_O.NIP.n14 VSS 1.22977f
C1706 XFRONT.XFE_O.NIP.t22 VSS 0.36688f
C1707 XFRONT.XFE_O.NIP.t23 VSS 0.37035f
C1708 XFRONT.XFE_O.NIP.n15 VSS 1.23967f
C1709 XFRONT.XFE_O.NIP.t5 VSS 0.36688f
C1710 XFRONT.XFE_O.NIP.t21 VSS 0.36688f
C1711 XFRONT.XFE_O.NIP.n16 VSS 1.22977f
C1712 XFRONT.XFE_O.NIP.n17 VSS 0.6459f
C1713 XFRONT.XFE_O.NIP.t3 VSS 0.36688f
C1714 XFRONT.XFE_O.NIP.t4 VSS 0.36688f
C1715 XFRONT.XFE_O.NIP.n18 VSS 1.22977f
C1716 XFRONT.XFE_O.NIP.n19 VSS 0.36463f
C1717 XFRONT.XFE_O.NIP.n20 VSS 0.93417f
C1718 XFRONT.XFE_O.NIP.n21 VSS 0.86596f
C1719 XFRONT.XFE_O.NIN.t6 VSS 0.37276f
C1720 XFRONT.XFE_O.NIN.t7 VSS 0.36932f
C1721 XFRONT.XFE_O.NIN.n0 VSS 1.25728f
C1722 XFRONT.XFE_O.NIN.t8 VSS 0.36932f
C1723 XFRONT.XFE_O.NIN.t3 VSS 0.36932f
C1724 XFRONT.XFE_O.NIN.n1 VSS 1.24724f
C1725 XFRONT.XFE_O.NIN.n2 VSS 0.65507f
C1726 XFRONT.XFE_O.NIN.t4 VSS 0.36932f
C1727 XFRONT.XFE_O.NIN.t5 VSS 0.36932f
C1728 XFRONT.XFE_O.NIN.n3 VSS 1.24724f
C1729 XFRONT.XFE_O.NIN.t10 VSS 0.36932f
C1730 XFRONT.XFE_O.NIN.t11 VSS 0.37276f
C1731 XFRONT.XFE_O.NIN.n4 VSS 1.25728f
C1732 XFRONT.XFE_O.NIN.t2 VSS 0.36932f
C1733 XFRONT.XFE_O.NIN.t9 VSS 0.36932f
C1734 XFRONT.XFE_O.NIN.n5 VSS 1.24724f
C1735 XFRONT.XFE_O.NIN.n6 VSS 0.65507f
C1736 XFRONT.XFE_O.NIN.t0 VSS 0.36932f
C1737 XFRONT.XFE_O.NIN.t1 VSS 0.36932f
C1738 XFRONT.XFE_O.NIN.n7 VSS 1.24724f
C1739 XFRONT.XFE_O.NIN.n8 VSS 0.36981f
C1740 XFRONT.XFE_O.NIN.n9 VSS 1.00904f
C1741 XFRONT.XFE_O.NIN.t15 VSS 1.67828f
C1742 XFRONT.XFE_O.NIN.t14 VSS 0.37249f
C1743 XFRONT.XFE_O.NIN.t13 VSS 0.37249f
C1744 XFRONT.XFE_O.NIN.n10 VSS 1.25651f
C1745 XFRONT.XFE_O.NIN.n11 VSS 0.61971f
C1746 XFRONT.XFE_O.NIN.t12 VSS 1.67404f
C1747 XFRONT.XFE_O.NIN.n12 VSS 3.4549f
C1748 XFRONT.XFE_O.NIN.n13 VSS 4.91382f
C1749 XFRONT.XFE_O.NIN.t23 VSS 1.60156f
C1750 XFRONT.XFE_O.NIN.t22 VSS 0.2973f
C1751 XFRONT.XFE_O.NIN.t21 VSS 0.2973f
C1752 XFRONT.XFE_O.NIN.n14 VSS 1.24724f
C1753 XFRONT.XFE_O.NIN.n15 VSS 0.70293f
C1754 XFRONT.XFE_O.NIN.t20 VSS 0.2973f
C1755 XFRONT.XFE_O.NIN.t19 VSS 0.2973f
C1756 XFRONT.XFE_O.NIN.n16 VSS 1.24724f
C1757 XFRONT.XFE_O.NIN.n17 VSS 0.29885f
C1758 XFRONT.XFE_O.NIN.t16 VSS 1.60156f
C1759 XFRONT.XFE_O.NIN.t18 VSS 0.2973f
C1760 XFRONT.XFE_O.NIN.t17 VSS 0.2973f
C1761 XFRONT.XFE_O.NIN.n18 VSS 1.24724f
C1762 XFRONT.XFE_O.NIN.n19 VSS 0.63197f
C1763 XFRONT.XFE_O.NIN.n20 VSS 0.98797f
C1764 XFRONT.XFE_O.NIN.n21 VSS 1.39363f
C1765 XFRONT.XFE_E.DN.t1 VSS 0.8912f
C1766 XFRONT.XFE_E.DN.t0 VSS 0.88596f
C1767 XFRONT.XFE_E.DN.n0 VSS 0.52546f
C1768 XFRONT.XFE_E.DN.n1 VSS 0.33878f
C1769 XFRONT.XFE_E.DN.n2 VSS 0.06346f
C1770 XFRONT.XFE_E.DN.n3 VSS 0.09808f
C1771 XFRONT.XFE_E.DN.n4 VSS 0.13746f
C1772 XFRONT.XFE_E.DN.n5 VSS 0.0636f
C1773 XFRONT.XFE_E.DN.n6 VSS 0.0636f
C1774 XFRONT.XFE_E.DN.n7 VSS 0.18512f
C1775 XFRONT.XFE_E.DN.n8 VSS 0.27157f
C1776 XFRONT.XFE_E.DN.n9 VSS 0.0915f
C1777 XFRONT.XFE_E.DN.n10 VSS 0.09808f
C1778 XFRONT.XFE_E.DN.n11 VSS 0.09808f
C1779 XFRONT.XFE_E.DN.n12 VSS 0.09808f
C1780 XFRONT.XFE_E.DN.n13 VSS 0.13746f
C1781 XFRONT.XFE_E.DN.n14 VSS 0.13746f
C1782 XFRONT.XFE_E.DN.n15 VSS 0.13732f
C1783 XFRONT.XFE_E.DN.n16 VSS 0.09808f
C1784 XFRONT.XFE_E.DN.n17 VSS 0.09808f
C1785 XFRONT.XFE_E.DN.n18 VSS 0.0894f
C1786 XFRONT.XFE_E.DN.n19 VSS 0.14833f
C1787 XFRONT.XFE_E.DN.n20 VSS 0.61121f
C1788 XFRONT.XFE_E.DN.t4 VSS 0.88923f
C1789 XFRONT.XFE_E.DN.t5 VSS 0.2868f
C1790 XFRONT.XFE_E.DN.t2 VSS 0.2868f
C1791 XFRONT.XFE_E.DN.n21 VSS 0.57969f
C1792 XFRONT.XFE_E.DN.n22 VSS 0.31864f
C1793 XFRONT.XFE_E.DN.t3 VSS 0.88738f
C1794 XFRONT.XFE_E.DN.n23 VSS 0.98658f
C1795 XFRONT.XFE_E.DN.n24 VSS 1.33585f
C1796 XFRONT.XFE_E.DP.n0 VSS 0.34607f
C1797 XFRONT.XFE_E.DP.n1 VSS 0.06467f
C1798 XFRONT.XFE_E.DP.n2 VSS 0.09996f
C1799 XFRONT.XFE_E.DP.n3 VSS 0.14009f
C1800 XFRONT.XFE_E.DP.n4 VSS 0.06482f
C1801 XFRONT.XFE_E.DP.n5 VSS 0.06482f
C1802 XFRONT.XFE_E.DP.n6 VSS 0.18866f
C1803 XFRONT.XFE_E.DP.n7 VSS 0.27676f
C1804 XFRONT.XFE_E.DP.n8 VSS 0.09325f
C1805 XFRONT.XFE_E.DP.n9 VSS 0.09996f
C1806 XFRONT.XFE_E.DP.n10 VSS 0.09996f
C1807 XFRONT.XFE_E.DP.n11 VSS 0.09996f
C1808 XFRONT.XFE_E.DP.n12 VSS 0.14009f
C1809 XFRONT.XFE_E.DP.n13 VSS 0.14009f
C1810 XFRONT.XFE_E.DP.n14 VSS 0.13994f
C1811 XFRONT.XFE_E.DP.n15 VSS 0.09996f
C1812 XFRONT.XFE_E.DP.n16 VSS 0.09996f
C1813 XFRONT.XFE_E.DP.n17 VSS 0.09111f
C1814 XFRONT.XFE_E.DP.n18 VSS 0.15109f
C1815 XFRONT.XFE_E.DP.n19 VSS 0.54741f
C1816 XFRONT.XFE_E.DP.t1 VSS 0.90102f
C1817 XFRONT.XFE_E.DP.t2 VSS 0.89965f
C1818 XFRONT.XFE_E.DP.n20 VSS 0.60387f
C1819 XFRONT.XFE_E.DP.t0 VSS 0.90157f
C1820 XFRONT.XFE_E.DP.t4 VSS 0.28762f
C1821 XFRONT.XFE_E.DP.t5 VSS 0.28762f
C1822 XFRONT.XFE_E.DP.n21 VSS 0.59078f
C1823 XFRONT.XFE_E.DP.n22 VSS 0.32473f
C1824 XFRONT.XFE_E.DP.t3 VSS 0.89959f
C1825 XFRONT.XFE_E.DP.n23 VSS 1.08581f
C1826 XFRONT.XFE_E.DP.n24 VSS 1.41978f
C1827 XFRONT.XFE_O.DP.t0 VSS 0.89965f
C1828 XFRONT.XFE_O.DP.t1 VSS 0.90102f
C1829 XFRONT.XFE_O.DP.n0 VSS 0.60387f
C1830 XFRONT.XFE_O.DP.t2 VSS 0.90157f
C1831 XFRONT.XFE_O.DP.t3 VSS 0.28762f
C1832 XFRONT.XFE_O.DP.t4 VSS 0.28762f
C1833 XFRONT.XFE_O.DP.n1 VSS 0.59078f
C1834 XFRONT.XFE_O.DP.n2 VSS 0.32473f
C1835 XFRONT.XFE_O.DP.t5 VSS 0.89959f
C1836 XFRONT.XFE_O.DP.n3 VSS 1.08581f
C1837 XFRONT.XFE_O.DP.n4 VSS 1.42483f
C1838 XFRONT.XFE_O.DP.n5 VSS 0.34607f
C1839 XFRONT.XFE_O.DP.n6 VSS 0.09111f
C1840 XFRONT.XFE_O.DP.n7 VSS 0.06482f
C1841 XFRONT.XFE_O.DP.n8 VSS 0.09996f
C1842 XFRONT.XFE_O.DP.n9 VSS 0.06482f
C1843 XFRONT.XFE_O.DP.n10 VSS 0.09996f
C1844 XFRONT.XFE_O.DP.n11 VSS 0.13994f
C1845 XFRONT.XFE_O.DP.n12 VSS 0.14009f
C1846 XFRONT.XFE_O.DP.n13 VSS 0.14009f
C1847 XFRONT.XFE_O.DP.n14 VSS 0.14009f
C1848 XFRONT.XFE_O.DP.n15 VSS 0.27676f
C1849 XFRONT.XFE_O.DP.n16 VSS 0.09325f
C1850 XFRONT.XFE_O.DP.n17 VSS 0.18866f
C1851 XFRONT.XFE_O.DP.n18 VSS 0.09996f
C1852 XFRONT.XFE_O.DP.n19 VSS 0.09996f
C1853 XFRONT.XFE_O.DP.n20 VSS 0.09996f
C1854 XFRONT.XFE_O.DP.n21 VSS 0.09996f
C1855 XFRONT.XFE_O.DP.n22 VSS 0.06467f
C1856 XFRONT.XFE_O.DP.n23 VSS 0.15109f
C1857 XFRONT.XFE_O.DP.n24 VSS 0.54719f
C1858 XFRONT.XFE_O.DP.n25 VSS 0.24004f
C1859 XFRONT.XFE_O.DN.n0 VSS 0.33878f
C1860 XFRONT.XFE_O.DN.n1 VSS 0.0894f
C1861 XFRONT.XFE_O.DN.n2 VSS 0.0636f
C1862 XFRONT.XFE_O.DN.n3 VSS 0.09808f
C1863 XFRONT.XFE_O.DN.n4 VSS 0.0636f
C1864 XFRONT.XFE_O.DN.n5 VSS 0.09808f
C1865 XFRONT.XFE_O.DN.n6 VSS 0.13732f
C1866 XFRONT.XFE_O.DN.n7 VSS 0.13746f
C1867 XFRONT.XFE_O.DN.n8 VSS 0.13746f
C1868 XFRONT.XFE_O.DN.n9 VSS 0.13746f
C1869 XFRONT.XFE_O.DN.n10 VSS 0.27157f
C1870 XFRONT.XFE_O.DN.n11 VSS 0.0915f
C1871 XFRONT.XFE_O.DN.n12 VSS 0.18512f
C1872 XFRONT.XFE_O.DN.n13 VSS 0.09808f
C1873 XFRONT.XFE_O.DN.n14 VSS 0.09808f
C1874 XFRONT.XFE_O.DN.n15 VSS 0.09808f
C1875 XFRONT.XFE_O.DN.n16 VSS 0.09808f
C1876 XFRONT.XFE_O.DN.n17 VSS 0.06346f
C1877 XFRONT.XFE_O.DN.n18 VSS 0.14833f
C1878 XFRONT.XFE_O.DN.n19 VSS 0.61121f
C1879 XFRONT.XFE_O.DN.t2 VSS 0.88923f
C1880 XFRONT.XFE_O.DN.t0 VSS 0.2868f
C1881 XFRONT.XFE_O.DN.t1 VSS 0.2868f
C1882 XFRONT.XFE_O.DN.n20 VSS 0.57969f
C1883 XFRONT.XFE_O.DN.n21 VSS 0.31864f
C1884 XFRONT.XFE_O.DN.t5 VSS 0.88738f
C1885 XFRONT.XFE_O.DN.n22 VSS 0.98658f
C1886 XFRONT.XFE_O.DN.n23 VSS 1.34081f
C1887 XFRONT.XFE_O.DN.t3 VSS 0.8912f
C1888 XFRONT.XFE_O.DN.t4 VSS 0.88596f
C1889 XFRONT.XFE_O.DN.n24 VSS 0.52459f
C1890 XFRONT.XFE_O.DN.n25 VSS 0.3408f
C1891 XFRONT.XFE_E.NTAIL.t20 VSS 0.17543f
C1892 XFRONT.XFE_E.NTAIL.t19 VSS 0.17394f
C1893 XFRONT.XFE_E.NTAIL.n0 VSS 0.61838f
C1894 XFRONT.XFE_E.NTAIL.t16 VSS 0.17394f
C1895 XFRONT.XFE_E.NTAIL.t15 VSS 0.17394f
C1896 XFRONT.XFE_E.NTAIL.n1 VSS 0.61345f
C1897 XFRONT.XFE_E.NTAIL.n2 VSS 0.32219f
C1898 XFRONT.XFE_E.NTAIL.t14 VSS 0.17394f
C1899 XFRONT.XFE_E.NTAIL.t13 VSS 0.17394f
C1900 XFRONT.XFE_E.NTAIL.n3 VSS 0.61345f
C1901 XFRONT.XFE_E.NTAIL.t18 VSS 0.17394f
C1902 XFRONT.XFE_E.NTAIL.t17 VSS 0.17542f
C1903 XFRONT.XFE_E.NTAIL.n4 VSS 0.61838f
C1904 XFRONT.XFE_E.NTAIL.n5 VSS 0.68153f
C1905 XFRONT.XFE_E.NTAIL.t44 VSS 1.01642f
C1906 XFRONT.XFE_E.NTAIL.t43 VSS 0.20524f
C1907 XFRONT.XFE_E.NTAIL.t42 VSS 0.20524f
C1908 XFRONT.XFE_E.NTAIL.n6 VSS 0.7709f
C1909 XFRONT.XFE_E.NTAIL.n7 VSS 0.36115f
C1910 XFRONT.XFE_E.NTAIL.t41 VSS 0.20524f
C1911 XFRONT.XFE_E.NTAIL.t40 VSS 0.20524f
C1912 XFRONT.XFE_E.NTAIL.n8 VSS 0.7709f
C1913 XFRONT.XFE_E.NTAIL.n9 VSS 0.18974f
C1914 XFRONT.XFE_E.NTAIL.t39 VSS 0.20524f
C1915 XFRONT.XFE_E.NTAIL.t38 VSS 0.20524f
C1916 XFRONT.XFE_E.NTAIL.n10 VSS 0.7709f
C1917 XFRONT.XFE_E.NTAIL.n11 VSS 0.18974f
C1918 XFRONT.XFE_E.NTAIL.t37 VSS 0.20524f
C1919 XFRONT.XFE_E.NTAIL.t36 VSS 0.20524f
C1920 XFRONT.XFE_E.NTAIL.n12 VSS 0.7709f
C1921 XFRONT.XFE_E.NTAIL.n13 VSS 0.18974f
C1922 XFRONT.XFE_E.NTAIL.t35 VSS 0.20524f
C1923 XFRONT.XFE_E.NTAIL.t34 VSS 0.20524f
C1924 XFRONT.XFE_E.NTAIL.n14 VSS 0.7709f
C1925 XFRONT.XFE_E.NTAIL.n15 VSS 0.15485f
C1926 XFRONT.XFE_E.NTAIL.t21 VSS 1.01642f
C1927 XFRONT.XFE_E.NTAIL.t23 VSS 0.20524f
C1928 XFRONT.XFE_E.NTAIL.t22 VSS 0.20524f
C1929 XFRONT.XFE_E.NTAIL.n16 VSS 0.7709f
C1930 XFRONT.XFE_E.NTAIL.n17 VSS 0.36115f
C1931 XFRONT.XFE_E.NTAIL.t25 VSS 0.20524f
C1932 XFRONT.XFE_E.NTAIL.t24 VSS 0.20524f
C1933 XFRONT.XFE_E.NTAIL.n18 VSS 0.7709f
C1934 XFRONT.XFE_E.NTAIL.n19 VSS 0.18974f
C1935 XFRONT.XFE_E.NTAIL.t27 VSS 0.20524f
C1936 XFRONT.XFE_E.NTAIL.t26 VSS 0.20524f
C1937 XFRONT.XFE_E.NTAIL.n20 VSS 0.7709f
C1938 XFRONT.XFE_E.NTAIL.n21 VSS 0.18974f
C1939 XFRONT.XFE_E.NTAIL.t29 VSS 0.20524f
C1940 XFRONT.XFE_E.NTAIL.t28 VSS 0.20524f
C1941 XFRONT.XFE_E.NTAIL.n22 VSS 0.7709f
C1942 XFRONT.XFE_E.NTAIL.n23 VSS 0.18974f
C1943 XFRONT.XFE_E.NTAIL.t31 VSS 0.20524f
C1944 XFRONT.XFE_E.NTAIL.t30 VSS 0.20524f
C1945 XFRONT.XFE_E.NTAIL.n24 VSS 0.7709f
C1946 XFRONT.XFE_E.NTAIL.n25 VSS 0.18974f
C1947 XFRONT.XFE_E.NTAIL.t33 VSS 0.20524f
C1948 XFRONT.XFE_E.NTAIL.t32 VSS 0.20524f
C1949 XFRONT.XFE_E.NTAIL.n26 VSS 0.7709f
C1950 XFRONT.XFE_E.NTAIL.n27 VSS 0.15485f
C1951 XFRONT.XFE_E.NTAIL.n28 VSS 0.27405f
C1952 XFRONT.XFE_E.NTAIL.t9 VSS 0.17523f
C1953 XFRONT.XFE_E.NTAIL.t8 VSS 0.17376f
C1954 XFRONT.XFE_E.NTAIL.n29 VSS 0.61838f
C1955 XFRONT.XFE_E.NTAIL.t7 VSS 0.17376f
C1956 XFRONT.XFE_E.NTAIL.t6 VSS 0.17376f
C1957 XFRONT.XFE_E.NTAIL.n30 VSS 0.61345f
C1958 XFRONT.XFE_E.NTAIL.n31 VSS 0.32219f
C1959 XFRONT.XFE_E.NTAIL.t5 VSS 0.17376f
C1960 XFRONT.XFE_E.NTAIL.t12 VSS 0.17376f
C1961 XFRONT.XFE_E.NTAIL.n32 VSS 0.61345f
C1962 XFRONT.XFE_E.NTAIL.t11 VSS 0.17376f
C1963 XFRONT.XFE_E.NTAIL.t10 VSS 0.17524f
C1964 XFRONT.XFE_E.NTAIL.n33 VSS 0.61838f
C1965 XFRONT.XFE_E.NTAIL.n34 VSS 0.68023f
C1966 XFRONT.XFE_E.NTAIL.n35 VSS 1.60812f
C1967 XFRONT.XFE_E.NTAIL.t4 VSS 1.11798f
C1968 XFRONT.XFE_E.NTAIL.t1 VSS 0.30981f
C1969 XFRONT.XFE_E.NTAIL.t0 VSS 0.31216f
C1970 XFRONT.XFE_E.NTAIL.n36 VSS 0.77602f
C1971 XFRONT.XFE_E.NTAIL.t3 VSS 0.30981f
C1972 XFRONT.XFE_E.NTAIL.t2 VSS 0.30981f
C1973 XFRONT.XFE_E.NTAIL.n37 VSS 0.7709f
C1974 XFRONT.XFE_E.NTAIL.n38 VSS 0.28537f
C1975 XFRONT.XFE_E.NTAIL.n39 VSS 0.25093f
C1976 XFRONT.XFE_E.NTAIL.n40 VSS 0.44253f
C1977 XFRONT.XFE_O.NTAIL.t36 VSS 1.01642f
C1978 XFRONT.XFE_O.NTAIL.t35 VSS 0.20524f
C1979 XFRONT.XFE_O.NTAIL.t34 VSS 0.20524f
C1980 XFRONT.XFE_O.NTAIL.n0 VSS 0.7709f
C1981 XFRONT.XFE_O.NTAIL.n1 VSS 0.36114f
C1982 XFRONT.XFE_O.NTAIL.t33 VSS 0.20524f
C1983 XFRONT.XFE_O.NTAIL.t32 VSS 0.20524f
C1984 XFRONT.XFE_O.NTAIL.n2 VSS 0.7709f
C1985 XFRONT.XFE_O.NTAIL.n3 VSS 0.18974f
C1986 XFRONT.XFE_O.NTAIL.t31 VSS 0.20524f
C1987 XFRONT.XFE_O.NTAIL.t30 VSS 0.20524f
C1988 XFRONT.XFE_O.NTAIL.n4 VSS 0.7709f
C1989 XFRONT.XFE_O.NTAIL.n5 VSS 0.18974f
C1990 XFRONT.XFE_O.NTAIL.t29 VSS 0.20524f
C1991 XFRONT.XFE_O.NTAIL.t28 VSS 0.20524f
C1992 XFRONT.XFE_O.NTAIL.n6 VSS 0.7709f
C1993 XFRONT.XFE_O.NTAIL.n7 VSS 0.18974f
C1994 XFRONT.XFE_O.NTAIL.t27 VSS 0.20524f
C1995 XFRONT.XFE_O.NTAIL.t26 VSS 0.20524f
C1996 XFRONT.XFE_O.NTAIL.n8 VSS 0.7709f
C1997 XFRONT.XFE_O.NTAIL.n9 VSS 0.18974f
C1998 XFRONT.XFE_O.NTAIL.t25 VSS 0.20524f
C1999 XFRONT.XFE_O.NTAIL.t24 VSS 0.20524f
C2000 XFRONT.XFE_O.NTAIL.n10 VSS 0.7709f
C2001 XFRONT.XFE_O.NTAIL.n11 VSS 0.15485f
C2002 XFRONT.XFE_O.NTAIL.t13 VSS 1.01642f
C2003 XFRONT.XFE_O.NTAIL.t15 VSS 0.20524f
C2004 XFRONT.XFE_O.NTAIL.t14 VSS 0.20524f
C2005 XFRONT.XFE_O.NTAIL.n12 VSS 0.7709f
C2006 XFRONT.XFE_O.NTAIL.n13 VSS 0.36114f
C2007 XFRONT.XFE_O.NTAIL.t17 VSS 0.20524f
C2008 XFRONT.XFE_O.NTAIL.t16 VSS 0.20524f
C2009 XFRONT.XFE_O.NTAIL.n14 VSS 0.7709f
C2010 XFRONT.XFE_O.NTAIL.n15 VSS 0.18974f
C2011 XFRONT.XFE_O.NTAIL.t19 VSS 0.20524f
C2012 XFRONT.XFE_O.NTAIL.t18 VSS 0.20524f
C2013 XFRONT.XFE_O.NTAIL.n16 VSS 0.7709f
C2014 XFRONT.XFE_O.NTAIL.n17 VSS 0.18974f
C2015 XFRONT.XFE_O.NTAIL.t21 VSS 0.20524f
C2016 XFRONT.XFE_O.NTAIL.t20 VSS 0.20524f
C2017 XFRONT.XFE_O.NTAIL.n18 VSS 0.7709f
C2018 XFRONT.XFE_O.NTAIL.n19 VSS 0.18974f
C2019 XFRONT.XFE_O.NTAIL.t23 VSS 0.20524f
C2020 XFRONT.XFE_O.NTAIL.t22 VSS 0.20524f
C2021 XFRONT.XFE_O.NTAIL.n20 VSS 0.7709f
C2022 XFRONT.XFE_O.NTAIL.n21 VSS 0.15485f
C2023 XFRONT.XFE_O.NTAIL.n22 VSS 0.27405f
C2024 XFRONT.XFE_O.NTAIL.t42 VSS 0.17543f
C2025 XFRONT.XFE_O.NTAIL.t41 VSS 0.17394f
C2026 XFRONT.XFE_O.NTAIL.n23 VSS 0.61838f
C2027 XFRONT.XFE_O.NTAIL.t44 VSS 0.17394f
C2028 XFRONT.XFE_O.NTAIL.t43 VSS 0.17394f
C2029 XFRONT.XFE_O.NTAIL.n24 VSS 0.61345f
C2030 XFRONT.XFE_O.NTAIL.t37 VSS 0.17394f
C2031 XFRONT.XFE_O.NTAIL.t40 VSS 0.17542f
C2032 XFRONT.XFE_O.NTAIL.n25 VSS 0.61838f
C2033 XFRONT.XFE_O.NTAIL.t39 VSS 0.17394f
C2034 XFRONT.XFE_O.NTAIL.t38 VSS 0.17394f
C2035 XFRONT.XFE_O.NTAIL.n26 VSS 0.61345f
C2036 XFRONT.XFE_O.NTAIL.n27 VSS 0.32219f
C2037 XFRONT.XFE_O.NTAIL.n28 VSS 0.68023f
C2038 XFRONT.XFE_O.NTAIL.n29 VSS 1.60812f
C2039 XFRONT.XFE_O.NTAIL.t4 VSS 0.31216f
C2040 XFRONT.XFE_O.NTAIL.t3 VSS 0.30981f
C2041 XFRONT.XFE_O.NTAIL.n30 VSS 0.77602f
C2042 XFRONT.XFE_O.NTAIL.t2 VSS 0.30981f
C2043 XFRONT.XFE_O.NTAIL.t1 VSS 0.30981f
C2044 XFRONT.XFE_O.NTAIL.n31 VSS 0.7709f
C2045 XFRONT.XFE_O.NTAIL.n32 VSS 0.28537f
C2046 XFRONT.XFE_O.NTAIL.t0 VSS 1.11798f
C2047 XFRONT.XFE_O.NTAIL.n33 VSS 0.25093f
C2048 XFRONT.XFE_O.NTAIL.n34 VSS 0.44781f
C2049 XFRONT.XFE_O.NTAIL.t5 VSS 0.17523f
C2050 XFRONT.XFE_O.NTAIL.t9 VSS 0.17376f
C2051 XFRONT.XFE_O.NTAIL.n35 VSS 0.61838f
C2052 XFRONT.XFE_O.NTAIL.t8 VSS 0.17376f
C2053 XFRONT.XFE_O.NTAIL.t7 VSS 0.17376f
C2054 XFRONT.XFE_O.NTAIL.n36 VSS 0.61345f
C2055 XFRONT.XFE_O.NTAIL.t11 VSS 0.17376f
C2056 XFRONT.XFE_O.NTAIL.t10 VSS 0.17524f
C2057 XFRONT.XFE_O.NTAIL.n37 VSS 0.61838f
C2058 XFRONT.XFE_O.NTAIL.t6 VSS 0.17376f
C2059 XFRONT.XFE_O.NTAIL.t12 VSS 0.17376f
C2060 XFRONT.XFE_O.NTAIL.n38 VSS 0.61345f
C2061 XFRONT.XFE_O.NTAIL.n39 VSS 0.32219f
C2062 XFRONT.XFE_O.NTAIL.n40 VSS 0.68023f
C2063 XFRONT.XFE_O.NTAIL.n41 VSS 0.4795f
C2064 a_n6716_3500.t0 VSS 0.46842f
C2065 a_n6716_3500.t1 VSS 0.9899f
C2066 a_n6572_3500.t4 VSS 0.52666f
C2067 a_n6572_3500.t0 VSS 0.12083f
C2068 a_n6572_3500.t1 VSS 0.12088f
C2069 a_n6572_3500.n0 VSS 0.18415f
C2070 a_n6572_3500.t3 VSS 0.38905f
C2071 a_n6572_3500.t2 VSS 0.15509f
C2072 a_n6572_3500.n1 VSS 1.38625f
C2073 a_n6572_3500.n2 VSS 0.64141f
C2074 a_n6572_3500.n3 VSS 0.84248f
C2075 a_n6572_3500.n4 VSS 2.72182f
C2076 a_n6572_3500.n5 VSS 0.25065f
C2077 a_n6572_3500.t5 VSS 0.52675f
C2078 a_n3600_5641.t0 VSS 0.49718f
C2079 a_n3600_5641.t4 VSS 0.12014f
C2080 a_n3600_5641.t5 VSS 0.1201f
C2081 a_n3600_5641.n0 VSS 0.18273f
C2082 a_n3600_5641.t3 VSS 0.3729f
C2083 a_n3600_5641.t2 VSS 0.1539f
C2084 a_n3600_5641.n1 VSS 1.37555f
C2085 a_n3600_5641.n2 VSS 0.55474f
C2086 a_n3600_5641.n3 VSS 1.07214f
C2087 a_n3600_5641.n4 VSS 2.44613f
C2088 a_n3600_5641.n5 VSS 0.28121f
C2089 a_n3600_5641.t1 VSS 0.49709f
C2090 a_n1900_5958.t1 VSS 0.5683f
C2091 a_n1900_5958.t0 VSS 1.16888f
C2092 a_484_3500.t1 VSS 0.57443f
C2093 a_484_3500.t0 VSS 1.18071f
C2094 a_5300_5958.t0 VSS 0.54596f
C2095 a_5300_5958.t1 VSS 1.13955f
C2096 a_n5052_2600.t5 VSS 0.03011f
C2097 a_n5052_2600.t7 VSS 0.12119f
C2098 a_n5052_2600.t4 VSS 0.12119f
C2099 a_n5052_2600.t3 VSS 0.04812f
C2100 a_n5052_2600.t2 VSS 0.04808f
C2101 a_n5052_2600.n0 VSS 0.10737f
C2102 a_n5052_2600.t1 VSS 0.04808f
C2103 a_n5052_2600.t0 VSS 0.04812f
C2104 a_n5052_2600.n1 VSS 0.10737f
C2105 a_n5052_2600.n2 VSS 0.98516f
C2106 a_n5052_2600.n3 VSS 0.46257f
C2107 a_n5052_2600.n4 VSS 0.09122f
C2108 a_n5052_2600.t6 VSS 0.03011f
C2109 a_n5052_n1000.t8 VSS 0.15606f
C2110 a_n5052_n1000.t6 VSS 0.15561f
C2111 a_n5052_n1000.t5 VSS 0.15561f
C2112 a_n5052_n1000.n0 VSS 0.45893f
C2113 a_n5052_n1000.n1 VSS 0.14951f
C2114 a_n5052_n1000.t4 VSS 0.65016f
C2115 a_n5052_n1000.n2 VSS 0.13501f
C2116 a_n5052_n1000.t0 VSS 0.14189f
C2117 a_n5052_n1000.t1 VSS 0.14189f
C2118 a_n5052_n1000.n3 VSS 0.50742f
C2119 a_n5052_n1000.t2 VSS 0.16772f
C2120 a_n5052_n1000.t3 VSS 0.16772f
C2121 a_n5052_n1000.n4 VSS 0.50742f
C2122 a_n5052_n1000.n5 VSS 1.21852f
C2123 a_n5052_n1000.n6 VSS 0.49183f
C2124 a_n5052_n1000.n7 VSS 0.11815f
C2125 a_n5052_n1000.n8 VSS 0.4607f
C2126 a_n5052_n1000.t7 VSS 0.15561f
C2127 a_2148_n500.t8 VSS 0.10916f
C2128 a_2148_n500.t6 VSS 0.10871f
C2129 a_2148_n500.t5 VSS 0.10871f
C2130 a_2148_n500.n0 VSS 0.28658f
C2131 a_2148_n500.n1 VSS 0.09336f
C2132 a_2148_n500.t4 VSS 0.4177f
C2133 a_2148_n500.n2 VSS 0.08431f
C2134 a_2148_n500.t1 VSS 0.08272f
C2135 a_2148_n500.t0 VSS 0.08272f
C2136 a_2148_n500.n3 VSS 0.17591f
C2137 a_2148_n500.t3 VSS 0.08306f
C2138 a_2148_n500.t2 VSS 0.08306f
C2139 a_2148_n500.n4 VSS 0.17591f
C2140 a_2148_n500.n5 VSS 0.81634f
C2141 a_2148_n500.n6 VSS 0.37461f
C2142 a_2148_n500.n7 VSS 0.07378f
C2143 a_2148_n500.n8 VSS 0.28768f
C2144 a_2148_n500.t7 VSS 0.10871f
C2145 a_n10800_n12572.n0 VSS 0.74217f
C2146 a_n10800_n12572.t1 VSS 0.12063f
C2147 a_n10800_n12572.n1 VSS 1.77193f
C2148 a_n10800_n12572.t0 VSS 0.16741f
C2149 a_n7300_n12700.t0 VSS 1.02298f
C2150 a_n7300_n12700.t3 VSS 0.97775f
C2151 a_n7300_n12700.t2 VSS 0.97215f
C2152 a_n7300_n12700.n0 VSS 0.54148f
C2153 a_n7300_n12700.t4 VSS 0.1493f
C2154 a_n7300_n12700.n1 VSS 2.1793f
C2155 a_n7300_n12700.n2 VSS 0.35701f
C2156 a_n7300_n12700.t1 VSS 1.01737f
C2157 a_n6400_n12652.t1 VSS 0.31174f
C2158 a_n6400_n12652.t3 VSS 0.26683f
C2159 a_n6400_n12652.t2 VSS 0.26683f
C2160 a_n6400_n12652.n0 VSS 0.82091f
C2161 a_n6400_n12652.t4 VSS 0.16832f
C2162 a_n6400_n12652.n1 VSS 2.87005f
C2163 a_n6400_n12652.n2 VSS 0.94209f
C2164 a_n6400_n12652.t0 VSS 0.31174f
C2165 a_n10800_n14372.n0 VSS 0.8249f
C2166 a_n10800_n14372.t1 VSS 0.12987f
C2167 a_n10800_n14372.n1 VSS 1.96946f
C2168 a_n10800_n14372.t0 VSS 0.18155f
C2169 a_n7300_n14500.t1 VSS 1.05346f
C2170 a_n7300_n14500.t0 VSS 1.01146f
C2171 a_n7300_n14500.t4 VSS 1.0057f
C2172 a_n7300_n14500.n0 VSS 0.55746f
C2173 a_n7300_n14500.t3 VSS 0.15371f
C2174 a_n7300_n14500.n1 VSS 2.24362f
C2175 a_n7300_n14500.n2 VSS 0.36754f
C2176 a_n7300_n14500.t2 VSS 1.04768f
C2177 a_n6400_n14452.t4 VSS 0.27216f
C2178 a_n6400_n14452.t0 VSS 0.16729f
C2179 a_n6400_n14452.t3 VSS 0.31383f
C2180 a_n6400_n14452.t2 VSS 0.31383f
C2181 a_n6400_n14452.n0 VSS 0.93635f
C2182 a_n6400_n14452.n1 VSS 2.85257f
C2183 a_n6400_n14452.n2 VSS 0.81591f
C2184 a_n6400_n14452.t1 VSS 0.27216f
C2185 a_n10800_n16172.n0 VSS 0.8249f
C2186 a_n10800_n16172.t1 VSS 0.12987f
C2187 a_n10800_n16172.n1 VSS 1.96946f
C2188 a_n10800_n16172.t0 VSS 0.18155f
C2189 a_n7300_n16300.t1 VSS 1.01146f
C2190 a_n7300_n16300.t0 VSS 1.0057f
C2191 a_n7300_n16300.n0 VSS 0.55746f
C2192 a_n7300_n16300.t2 VSS 0.15371f
C2193 a_n7300_n16300.n1 VSS 2.24362f
C2194 a_n7300_n16300.t4 VSS 1.04768f
C2195 a_n7300_n16300.n2 VSS 0.36754f
C2196 a_n7300_n16300.t3 VSS 1.05346f
C2197 a_n6400_n16252.t2 VSS 0.27216f
C2198 a_n6400_n16252.t0 VSS 0.16729f
C2199 a_n6400_n16252.t4 VSS 0.31383f
C2200 a_n6400_n16252.t3 VSS 0.31383f
C2201 a_n6400_n16252.n0 VSS 0.93635f
C2202 a_n6400_n16252.n1 VSS 2.85257f
C2203 a_n6400_n16252.n2 VSS 0.81591f
C2204 a_n6400_n16252.t1 VSS 0.27216f
C2205 a_n10800_n17972.n0 VSS 0.8249f
C2206 a_n10800_n17972.t1 VSS 0.12987f
C2207 a_n10800_n17972.n1 VSS 1.96946f
C2208 a_n10800_n17972.t0 VSS 0.18155f
C2209 a_n7300_n18100.t0 VSS 1.05346f
C2210 a_n7300_n18100.t3 VSS 1.01146f
C2211 a_n7300_n18100.t2 VSS 1.0057f
C2212 a_n7300_n18100.n0 VSS 0.55746f
C2213 a_n7300_n18100.t4 VSS 0.15371f
C2214 a_n7300_n18100.n1 VSS 2.24362f
C2215 a_n7300_n18100.n2 VSS 0.36754f
C2216 a_n7300_n18100.t1 VSS 1.04768f
C2217 a_n6400_n18052.t1 VSS 0.31383f
C2218 a_n6400_n18052.t3 VSS 0.27216f
C2219 a_n6400_n18052.t2 VSS 0.27216f
C2220 a_n6400_n18052.n0 VSS 0.81591f
C2221 a_n6400_n18052.t4 VSS 0.16729f
C2222 a_n6400_n18052.n1 VSS 2.85257f
C2223 a_n6400_n18052.n2 VSS 0.93635f
C2224 a_n6400_n18052.t0 VSS 0.31383f
C2225 a_n10800_n19772.n0 VSS 0.8249f
C2226 a_n10800_n19772.t1 VSS 0.12987f
C2227 a_n10800_n19772.n1 VSS 1.96946f
C2228 a_n10800_n19772.t0 VSS 0.18155f
C2229 a_n7300_n19900.t0 VSS 1.05359f
C2230 a_n7300_n19900.t3 VSS 1.01158f
C2231 a_n7300_n19900.t2 VSS 1.00582f
C2232 a_n7300_n19900.n0 VSS 0.55754f
C2233 a_n7300_n19900.t4 VSS 0.15373f
C2234 a_n7300_n19900.n1 VSS 2.24392f
C2235 a_n7300_n19900.n2 VSS 0.36759f
C2236 a_n7300_n19900.t1 VSS 1.0478f
C2237 a_n6400_n19852.t1 VSS 0.31383f
C2238 a_n6400_n19852.t4 VSS 0.27216f
C2239 a_n6400_n19852.t3 VSS 0.27216f
C2240 a_n6400_n19852.n0 VSS 0.81591f
C2241 a_n6400_n19852.t2 VSS 0.16729f
C2242 a_n6400_n19852.n1 VSS 2.85257f
C2243 a_n6400_n19852.n2 VSS 0.93635f
C2244 a_n6400_n19852.t0 VSS 0.31383f
C2245 a_n10800_n21572.n0 VSS 0.82349f
C2246 a_n10800_n21572.t1 VSS 0.12929f
C2247 a_n10800_n21572.n1 VSS 1.96608f
C2248 a_n10800_n21572.t0 VSS 0.18086f
C2249 a_n7157_n21700.t1 VSS 1.05367f
C2250 a_n7157_n21700.t4 VSS 1.01242f
C2251 a_n7157_n21700.t3 VSS 1.00665f
C2252 a_n7157_n21700.n0 VSS 0.5581f
C2253 a_n7157_n21700.t0 VSS 0.15048f
C2254 a_n7157_n21700.n1 VSS 2.16743f
C2255 a_n7157_n21700.n2 VSS 0.36796f
C2256 a_n7157_n21700.t2 VSS 1.04788f
C2257 a_n6400_n21652.t1 VSS 0.31401f
C2258 a_n6400_n21652.t4 VSS 0.27309f
C2259 a_n6400_n21652.t3 VSS 0.27309f
C2260 a_n6400_n21652.n0 VSS 0.82003f
C2261 a_n6400_n21652.t2 VSS 0.16442f
C2262 a_n6400_n21652.n1 VSS 2.78096f
C2263 a_n6400_n21652.n2 VSS 0.94109f
C2264 a_n6400_n21652.t0 VSS 0.31401f
C2265 a_n10800_n23372.n0 VSS 0.78687f
C2266 a_n10800_n23372.t1 VSS 0.12249f
C2267 a_n10800_n23372.n1 VSS 1.87864f
C2268 a_n10800_n23372.t0 VSS 0.17169f
C2269 a_n7157_n23500.t2 VSS 0.94316f
C2270 a_n7157_n23500.t1 VSS 0.9378f
C2271 a_n7157_n23500.n0 VSS 0.51899f
C2272 a_n7157_n23500.t0 VSS 0.13994f
C2273 a_n7157_n23500.n1 VSS 2.01556f
C2274 a_n7157_n23500.t4 VSS 0.97513f
C2275 a_n7157_n23500.n2 VSS 0.34218f
C2276 a_n7157_n23500.t3 VSS 0.98051f
C2277 a_n6400_n23452.t2 VSS 0.26779f
C2278 a_n6400_n23452.t0 VSS 0.16253f
C2279 a_n6400_n23452.t3 VSS 0.30483f
C2280 a_n6400_n23452.t4 VSS 0.30483f
C2281 a_n6400_n23452.n0 VSS 0.93029f
C2282 a_n6400_n23452.n1 VSS 2.74905f
C2283 a_n6400_n23452.n2 VSS 0.81062f
C2284 a_n6400_n23452.t1 VSS 0.26779f
C2285 VSS.t384 VSS 0.05093f
C2286 VSS.t143 VSS 0.05439f
C2287 VSS.t132 VSS 0.05484f
C2288 VSS.t142 VSS 0.05484f
C2289 VSS.t324 VSS 0.05484f
C2290 VSS.t323 VSS 0.05484f
C2291 VSS.t44 VSS 0.05312f
C2292 VSS.t498 VSS 0.03117f
C2293 VSS.t497 VSS 0.03072f
C2294 VSS.t496 VSS 0.03072f
C2295 VSS.t495 VSS 0.03072f
C2296 VSS.t494 VSS 0.03117f
C2297 VSS.t95 VSS 0.13813f
C2298 VSS.t1 VSS 0.13813f
C2299 VSS.t93 VSS 0.14078f
C2300 VSS.t40 VSS 0.0866f
C2301 VSS.t434 VSS 0.08665f
C2302 VSS.t90 VSS 0.05453f
C2303 VSS.t86 VSS 0.0535f
C2304 VSS.t85 VSS 0.0535f
C2305 VSS.t88 VSS 0.05453f
C2306 VSS.t140 VSS 0.0513f
C2307 VSS.t138 VSS 0.05034f
C2308 VSS.t136 VSS 0.05034f
C2309 VSS.t134 VSS 0.0513f
C2310 VSS.t151 VSS 0.16234f
C2311 VSS.t153 VSS 0.16234f
C2312 VSS.t256 VSS 0.04435f
C2313 VSS.t254 VSS 0.04352f
C2314 VSS.t249 VSS 0.04352f
C2315 VSS.t247 VSS 0.04435f
C2316 VSS.t250 VSS 0.04352f
C2317 VSS.t245 VSS 0.04352f
C2318 VSS.t252 VSS 0.04352f
C2319 VSS.t251 VSS 0.04352f
C2320 VSS.t159 VSS 0.12931f
C2321 VSS.t3 VSS 0.13179f
C2322 VSS.t42 VSS 0.12931f
C2323 VSS.t36 VSS 0.16084f
C2324 VSS.t38 VSS 0.16084f
C2325 VSS.t267 VSS 0.04352f
C2326 VSS.t265 VSS 0.04352f
C2327 VSS.t260 VSS 0.04352f
C2328 VSS.t258 VSS 0.04435f
C2329 VSS.t261 VSS 0.04352f
C2330 VSS.t244 VSS 0.04352f
C2331 VSS.t263 VSS 0.04352f
C2332 VSS.t262 VSS 0.04352f
C2333 VSS.t187 VSS 0.08741f
C2334 VSS.t189 VSS 0.08746f
C2335 VSS.t416 VSS 0.08484f
C2336 VSS.t326 VSS 0.08489f
C2337 VSS.t155 VSS 0.16189f
C2338 VSS.t314 VSS 0.16189f
C2339 VSS.t507 VSS 0.12632f
C2340 VSS.t505 VSS 0.12632f
C2341 VSS.t19 VSS 0.12874f
C2342 VSS.t73 VSS 0.03497f
C2343 VSS.t71 VSS 0.03497f
C2344 VSS.t69 VSS 0.03497f
C2345 VSS.t68 VSS 0.03497f
C2346 VSS.t66 VSS 0.03497f
C2347 VSS.t50 VSS 0.03564f
C2348 VSS.t48 VSS 0.03497f
C2349 VSS.t67 VSS 0.03497f
C2350 VSS.t320 VSS 0.15757f
C2351 VSS.t414 VSS 0.15757f
C2352 VSS.t64 VSS 0.03564f
C2353 VSS.t62 VSS 0.03497f
C2354 VSS.t54 VSS 0.03497f
C2355 VSS.t52 VSS 0.03564f
C2356 VSS.t57 VSS 0.03497f
C2357 VSS.t55 VSS 0.03497f
C2358 VSS.t60 VSS 0.03497f
C2359 VSS.t59 VSS 0.03497f
C2360 VSS.t393 VSS 0.05568f
C2361 VSS.t391 VSS 0.05464f
C2362 VSS.t389 VSS 0.05464f
C2363 VSS.t387 VSS 0.05568f
C2364 VSS.t315 VSS 0.08717f
C2365 VSS.t160 VSS 0.08721f
C2366 VSS.t114 VSS 0.05853f
C2367 VSS.t108 VSS 0.05742f
C2368 VSS.t112 VSS 0.05742f
C2369 VSS.t110 VSS 0.05853f
C2370 VSS.t413 VSS 0.13279f
C2371 VSS.t5 VSS 0.13279f
C2372 VSS.t157 VSS 0.13533f
C2373 VSS.t130 VSS 0.12332f
C2374 VSS.t177 VSS 0.12332f
C2375 VSS.t179 VSS 0.12332f
C2376 VSS.t381 VSS 0.12568f
C2377 VSS.t433 VSS 0.14369f
C2378 VSS.t26 VSS 0.17813f
C2379 VSS.t28 VSS 0.17816f
C2380 VSS.t472 VSS 0.05718f
C2381 VSS.t480 VSS 0.056f
C2382 VSS.t478 VSS 0.056f
C2383 VSS.t476 VSS 0.056f
C2384 VSS.t474 VSS 0.056f
C2385 VSS.t470 VSS 0.056f
C2386 VSS.t456 VSS 0.056f
C2387 VSS.t468 VSS 0.056f
C2388 VSS.t466 VSS 0.056f
C2389 VSS.t458 VSS 0.056f
C2390 VSS.t464 VSS 0.056f
C2391 VSS.t462 VSS 0.056f
C2392 VSS.t460 VSS 0.056f
C2393 VSS.t454 VSS 0.056f
C2394 VSS.t106 VSS 0.16057f
C2395 VSS.t104 VSS 0.16057f
C2396 VSS.t102 VSS 0.16057f
C2397 VSS.t98 VSS 0.16057f
C2398 VSS.t100 VSS 0.16292f
C2399 VSS.t124 VSS 0.17682f
C2400 VSS.t204 VSS 0.17678f
C2401 VSS.t425 VSS 0.11641f
C2402 VSS.t427 VSS 0.11641f
C2403 VSS.t429 VSS 0.11641f
C2404 VSS.t431 VSS 0.11864f
C2405 VSS.t420 VSS 0.07271f
C2406 VSS.t209 VSS 0.07078f
C2407 VSS.t353 VSS 0.07078f
C2408 VSS.t510 VSS 0.07078f
C2409 VSS.t202 VSS 0.07078f
C2410 VSS.t512 VSS 0.07078f
C2411 VSS.t500 VSS 0.07078f
C2412 VSS.t317 VSS 0.0727f
C2413 VSS.t128 VSS 0.15863f
C2414 VSS.t452 VSS 0.056f
C2415 VSS.t438 VSS 0.056f
C2416 VSS.t442 VSS 0.056f
C2417 VSS.t436 VSS 0.05718f
C2418 VSS.t446 VSS 0.056f
C2419 VSS.t444 VSS 0.056f
C2420 VSS.t440 VSS 0.056f
C2421 VSS.t448 VSS 0.056f
C2422 VSS.t450 VSS 0.056f
C2423 VSS.t449 VSS 0.056f
C2424 VSS.t199 VSS 0.07134f
C2425 VSS.t329 VSS 0.06945f
C2426 VSS.t175 VSS 0.06945f
C2427 VSS.t197 VSS 0.06945f
C2428 VSS.t126 VSS 0.06945f
C2429 VSS.t362 VSS 0.06945f
C2430 VSS.t213 VSS 0.06945f
C2431 VSS.t170 VSS 0.07134f
C2432 VSS.t492 VSS 0.03072f
C2433 VSS.t490 VSS 0.03072f
C2434 VSS.t493 VSS 0.03117f
C2435 VSS.t488 VSS 0.03072f
C2436 VSS.t489 VSS 0.03117f
C2437 VSS.t375 VSS 0.07134f
C2438 VSS.t351 VSS 0.06945f
C2439 VSS.t370 VSS 0.06945f
C2440 VSS.t368 VSS 0.07134f
C2441 VSS.t364 VSS 0.06945f
C2442 VSS.t373 VSS 0.06945f
C2443 VSS.t358 VSS 0.06945f
C2444 VSS.t356 VSS 0.06945f
C2445 VSS.t301 VSS 0.05718f
C2446 VSS.t305 VSS 0.056f
C2447 VSS.t303 VSS 0.056f
C2448 VSS.t307 VSS 0.056f
C2449 VSS.t313 VSS 0.056f
C2450 VSS.t311 VSS 0.056f
C2451 VSS.t309 VSS 0.056f
C2452 VSS.t308 VSS 0.056f
C2453 VSS.t79 VSS 0.17816f
C2454 VSS.t81 VSS 0.17813f
C2455 VSS.t226 VSS 0.16292f
C2456 VSS.t218 VSS 0.16057f
C2457 VSS.t220 VSS 0.16057f
C2458 VSS.t224 VSS 0.16057f
C2459 VSS.t222 VSS 0.16057f
C2460 VSS.t10 VSS 0.17678f
C2461 VSS.t12 VSS 0.17682f
C2462 VSS.t345 VSS 0.11864f
C2463 VSS.t347 VSS 0.11641f
C2464 VSS.t339 VSS 0.11641f
C2465 VSS.t341 VSS 0.11641f
C2466 VSS.t379 VSS 0.07078f
C2467 VSS.t349 VSS 0.07271f
C2468 VSS.t166 VSS 0.07078f
C2469 VSS.t377 VSS 0.07078f
C2470 VSS.t418 VSS 0.07078f
C2471 VSS.t207 VSS 0.07078f
C2472 VSS.t168 VSS 0.0727f
C2473 VSS.t192 VSS 0.07078f
C2474 VSS.t337 VSS 0.15863f
C2475 VSS.t273 VSS 0.056f
C2476 VSS.t271 VSS 0.05718f
C2477 VSS.t277 VSS 0.056f
C2478 VSS.t275 VSS 0.056f
C2479 VSS.t279 VSS 0.056f
C2480 VSS.t269 VSS 0.056f
C2481 VSS.t285 VSS 0.056f
C2482 VSS.t281 VSS 0.056f
C2483 VSS.t289 VSS 0.056f
C2484 VSS.t287 VSS 0.056f
C2485 VSS.t283 VSS 0.056f
C2486 VSS.t291 VSS 0.056f
C2487 VSS.t295 VSS 0.056f
C2488 VSS.t293 VSS 0.056f
C2489 VSS.t299 VSS 0.056f
C2490 VSS.t297 VSS 0.056f
C2491 VSS.t343 VSS 0.14369f
C2492 VSS.t319 VSS 0.12568f
C2493 VSS.t331 VSS 0.12332f
C2494 VSS.t333 VSS 0.12332f
C2495 VSS.t335 VSS 0.12332f
C2496 VDD.t409 VSS 0.68782f
C2497 VDD.t408 VSS 0.61903f
C2498 VDD.t177 VSS 0.61903f
C2499 VDD.t176 VSS 0.61903f
C2500 VDD.t153 VSS 0.61903f
C2501 VDD.t152 VSS 0.61903f
C2502 VDD.t173 VSS 0.61903f
C2503 VDD.t172 VSS 0.61903f
C2504 VDD.t368 VSS 0.61903f
C2505 VDD.t367 VSS 0.61903f
C2506 VDD.t364 VSS 0.61903f
C2507 VDD.t363 VSS 0.61903f
C2508 VDD.t30 VSS 0.61903f
C2509 VDD.t29 VSS 0.34898f
C2510 VDD.t28 VSS 0.07933f
C2511 VDD.t362 VSS 0.08117f
C2512 VDD.n0 VSS 0.07781f
C2513 VDD.t27 VSS 0.45407f
C2514 VDD.t365 VSS 0.31435f
C2515 VDD.t366 VSS 0.08117f
C2516 VDD.t171 VSS 0.08117f
C2517 VDD.n1 VSS 0.07781f
C2518 VDD.t150 VSS 0.31435f
C2519 VDD.t151 VSS 0.08117f
C2520 VDD.t175 VSS 0.08069f
C2521 VDD.n2 VSS 0.07781f
C2522 VDD.t406 VSS 0.32569f
C2523 VDD.t407 VSS 0.07697f
C2524 VDD.n3 VSS 0.33704f
C2525 VDD.n4 VSS 0.05373f
C2526 VDD.n5 VSS 0.32228f
C2527 VDD.t174 VSS 0.31435f
C2528 VDD.n6 VSS 0.32228f
C2529 VDD.n7 VSS 0.05373f
C2530 VDD.n8 VSS 0.07781f
C2531 VDD.n9 VSS 0.05373f
C2532 VDD.n10 VSS 0.32228f
C2533 VDD.t170 VSS 0.31435f
C2534 VDD.n11 VSS 0.32228f
C2535 VDD.n12 VSS 0.05373f
C2536 VDD.n13 VSS 0.07781f
C2537 VDD.n14 VSS 0.05373f
C2538 VDD.n15 VSS 0.32228f
C2539 VDD.t361 VSS 0.31435f
C2540 VDD.n16 VSS 0.32228f
C2541 VDD.n17 VSS 0.05373f
C2542 VDD.n18 VSS 0.18304f
C2543 VDD.n19 VSS 2.5561f
C2544 VDD.n20 VSS 13.5446f
C2545 VDD.t347 VSS 1.37026f
C2546 VDD.t348 VSS 1.64431f
C2547 VDD.t349 VSS 1.64431f
C2548 VDD.t350 VSS 1.25886f
C2549 VDD.t207 VSS 0.02979f
C2550 VDD.t206 VSS 0.03284f
C2551 VDD.n21 VSS 0.19724f
C2552 VDD.t149 VSS 0.03284f
C2553 VDD.n22 VSS 0.10066f
C2554 VDD.t471 VSS 0.0284f
C2555 VDD.n23 VSS 0.12485f
C2556 VDD.t426 VSS 0.0284f
C2557 VDD.n24 VSS 0.37201f
C2558 VDD.t31 VSS 0.03519f
C2559 VDD.n25 VSS 0.37035f
C2560 VDD.t208 VSS 0.03519f
C2561 VDD.n26 VSS 0.37035f
C2562 VDD.t227 VSS 0.0284f
C2563 VDD.n27 VSS 0.27583f
C2564 VDD.n28 VSS 5.24758f
C2565 VDD.n29 VSS 0.20798f
C2566 VDD.n30 VSS 0.06923f
C2567 VDD.n31 VSS 0.10112f
C2568 VDD.n32 VSS 0.09672f
C2569 VDD.t139 VSS 0.64483f
C2570 VDD.n33 VSS 0.09672f
C2571 VDD.n34 VSS 0.10112f
C2572 VDD.n35 VSS 0.10309f
C2573 VDD.n36 VSS 0.10112f
C2574 VDD.n37 VSS 0.09672f
C2575 VDD.t16 VSS 2.45035f
C2576 VDD.n38 VSS 0.27211f
C2577 VDD.t188 VSS 0.3869f
C2578 VDD.n39 VSS 0.09672f
C2579 VDD.n40 VSS 0.10112f
C2580 VDD.n41 VSS 0.10309f
C2581 VDD.n42 VSS 0.10112f
C2582 VDD.n43 VSS 0.09672f
C2583 VDD.t431 VSS 0.64483f
C2584 VDD.n44 VSS 0.09672f
C2585 VDD.n45 VSS 0.10112f
C2586 VDD.n46 VSS 0.10309f
C2587 VDD.n47 VSS 0.10112f
C2588 VDD.n48 VSS 0.09672f
C2589 VDD.t331 VSS 0.3869f
C2590 VDD.n49 VSS 0.43665f
C2591 VDD.t154 VSS 0.64483f
C2592 VDD.n50 VSS 0.09672f
C2593 VDD.n51 VSS 0.10112f
C2594 VDD.n52 VSS 0.08653f
C2595 VDD.n53 VSS 0.10112f
C2596 VDD.n54 VSS 0.09672f
C2597 VDD.n55 VSS 4.93635f
C2598 VDD.n56 VSS 3.71708f
C2599 VDD.n57 VSS 1.54759f
C2600 VDD.t4 VSS 0.51586f
C2601 VDD.t182 VSS 0.51586f
C2602 VDD.t217 VSS 0.51586f
C2603 VDD.t215 VSS 2.45035f
C2604 VDD.t160 VSS 0.51586f
C2605 VDD.t164 VSS 0.51586f
C2606 VDD.t158 VSS 0.51586f
C2607 VDD.t168 VSS 0.51586f
C2608 VDD.t156 VSS 0.51586f
C2609 VDD.t166 VSS 0.51586f
C2610 VDD.t162 VSS 1.28966f
C2611 VDD.n58 VSS 2.23799f
C2612 VDD.t45 VSS 1.28966f
C2613 VDD.t49 VSS 0.51586f
C2614 VDD.t53 VSS 0.51586f
C2615 VDD.t57 VSS 0.51586f
C2616 VDD.t59 VSS 0.51586f
C2617 VDD.t55 VSS 0.51586f
C2618 VDD.t51 VSS 0.51586f
C2619 VDD.t47 VSS 0.64483f
C2620 VDD.n59 VSS 2.57931f
C2621 VDD.n60 VSS 0.09672f
C2622 VDD.n61 VSS 0.10112f
C2623 VDD.n62 VSS 0.27907f
C2624 VDD.n63 VSS 0.10309f
C2625 VDD.n64 VSS 0.10309f
C2626 VDD.n65 VSS 0.10112f
C2627 VDD.n66 VSS 0.09672f
C2628 VDD.n67 VSS 2.57931f
C2629 VDD.t44 VSS 2.45035f
C2630 VDD.t12 VSS 0.51586f
C2631 VDD.t13 VSS 0.51586f
C2632 VDD.t23 VSS 0.51586f
C2633 VDD.n68 VSS 1.54759f
C2634 VDD.t335 VSS 0.51586f
C2635 VDD.t337 VSS 0.51586f
C2636 VDD.t333 VSS 1.28966f
C2637 VDD.n69 VSS 2.49593f
C2638 VDD.n70 VSS 0.27211f
C2639 VDD.n71 VSS 0.27211f
C2640 VDD.n72 VSS 0.43248f
C2641 VDD.t429 VSS 2.57931f
C2642 VDD.n73 VSS 3.35311f
C2643 VDD.t25 VSS 1.16069f
C2644 VDD.t231 VSS 0.51586f
C2645 VDD.t32 VSS 0.51586f
C2646 VDD.t34 VSS 0.90276f
C2647 VDD.t327 VSS 0.90276f
C2648 VDD.t323 VSS 0.51586f
C2649 VDD.t325 VSS 0.51586f
C2650 VDD.t329 VSS 0.3869f
C2651 VDD.n74 VSS 0.25793f
C2652 VDD.n75 VSS 0.09672f
C2653 VDD.n76 VSS 0.10112f
C2654 VDD.n77 VSS 0.10309f
C2655 VDD.n78 VSS 0.10309f
C2656 VDD.n79 VSS 0.10309f
C2657 VDD.n80 VSS 0.10112f
C2658 VDD.n81 VSS 0.09672f
C2659 VDD.n82 VSS 3.74f
C2660 VDD.n83 VSS 6.44828f
C2661 VDD.t251 VSS 0.51586f
C2662 VDD.t243 VSS 0.51586f
C2663 VDD.t241 VSS 0.90276f
C2664 VDD.t14 VSS 0.90276f
C2665 VDD.t194 VSS 0.51586f
C2666 VDD.t427 VSS 0.51586f
C2667 VDD.t223 VSS 1.16069f
C2668 VDD.n84 VSS 3.35311f
C2669 VDD.t42 VSS 2.57931f
C2670 VDD.n85 VSS 0.43248f
C2671 VDD.t229 VSS 0.64483f
C2672 VDD.n86 VSS 3.74f
C2673 VDD.n87 VSS 0.09672f
C2674 VDD.n88 VSS 0.10112f
C2675 VDD.n89 VSS 0.10309f
C2676 VDD.n90 VSS 0.10309f
C2677 VDD.n91 VSS 0.10309f
C2678 VDD.n92 VSS 0.10112f
C2679 VDD.n93 VSS 0.09672f
C2680 VDD.n94 VSS 0.25793f
C2681 VDD.t184 VSS 0.3869f
C2682 VDD.t237 VSS 0.51586f
C2683 VDD.t239 VSS 0.51586f
C2684 VDD.t245 VSS 1.28966f
C2685 VDD.t3 VSS 0.51586f
C2686 VDD.t2 VSS 0.51586f
C2687 VDD.t24 VSS 0.51586f
C2688 VDD.n95 VSS 1.54759f
C2689 VDD.n96 VSS 2.49593f
C2690 VDD.n97 VSS 0.27211f
C2691 VDD.n98 VSS 0.26803f
C2692 VDD.t133 VSS 0.51586f
C2693 VDD.t135 VSS 0.51586f
C2694 VDD.t129 VSS 0.51586f
C2695 VDD.t137 VSS 0.51586f
C2696 VDD.t141 VSS 0.51586f
C2697 VDD.t131 VSS 0.51586f
C2698 VDD.t143 VSS 1.28966f
C2699 VDD.n99 VSS 2.23799f
C2700 VDD.t416 VSS 1.28966f
C2701 VDD.t410 VSS 0.51586f
C2702 VDD.t414 VSS 0.51586f
C2703 VDD.t418 VSS 0.51586f
C2704 VDD.t412 VSS 0.51586f
C2705 VDD.t420 VSS 0.51586f
C2706 VDD.t424 VSS 0.51586f
C2707 VDD.t422 VSS 0.64483f
C2708 VDD.n100 VSS 2.57931f
C2709 VDD.n101 VSS 0.09672f
C2710 VDD.n102 VSS 0.10112f
C2711 VDD.n103 VSS 0.10309f
C2712 VDD.n104 VSS 0.10309f
C2713 VDD.n105 VSS 0.10309f
C2714 VDD.n106 VSS 0.10112f
C2715 VDD.n107 VSS 0.09672f
C2716 VDD.n108 VSS 2.57931f
C2717 VDD.t457 VSS 2.45035f
C2718 VDD.t21 VSS 0.51586f
C2719 VDD.t235 VSS 0.51586f
C2720 VDD.t233 VSS 0.51586f
C2721 VDD.n109 VSS 1.54759f
C2722 VDD.n110 VSS 3.70476f
C2723 VDD.n111 VSS 4.93027f
C2724 VDD.n112 VSS 0.08295f
C2725 VDD.n113 VSS 0.1203f
C2726 VDD.n114 VSS 0.06055f
C2727 VDD.t189 VSS 0.17307f
C2728 VDD.t185 VSS 0.17307f
C2729 VDD.n115 VSS 0.09116f
C2730 VDD.t195 VSS 0.1375f
C2731 VDD.t15 VSS 0.13992f
C2732 VDD.n116 VSS 0.05831f
C2733 VDD.t224 VSS 0.13992f
C2734 VDD.t428 VSS 0.1375f
C2735 VDD.n117 VSS 0.05786f
C2736 VDD.n118 VSS 0.02911f
C2737 VDD.n119 VSS 0.14935f
C2738 VDD.t254 VSS 0.07574f
C2739 VDD.t246 VSS 0.07574f
C2740 VDD.n120 VSS 0.05831f
C2741 VDD.t256 VSS 0.07574f
C2742 VDD.t238 VSS 0.07574f
C2743 VDD.n121 VSS 0.05786f
C2744 VDD.n122 VSS 0.02932f
C2745 VDD.t257 VSS 0.07574f
C2746 VDD.t255 VSS 0.07574f
C2747 VDD.n123 VSS 0.05786f
C2748 VDD.n124 VSS 0.0166f
C2749 VDD.t242 VSS 0.07698f
C2750 VDD.t258 VSS 0.07574f
C2751 VDD.n125 VSS 0.05786f
C2752 VDD.n126 VSS 0.0166f
C2753 VDD.n127 VSS 0.0512f
C2754 VDD.n128 VSS 0.14941f
C2755 VDD.n129 VSS 0.08951f
C2756 VDD.t430 VSS 0.1735f
C2757 VDD.t432 VSS 0.17353f
C2758 VDD.n130 VSS 0.10551f
C2759 VDD.t35 VSS 0.14297f
C2760 VDD.t33 VSS 0.14049f
C2761 VDD.n131 VSS 0.05831f
C2762 VDD.t232 VSS 0.14049f
C2763 VDD.t26 VSS 0.14297f
C2764 VDD.n132 VSS 0.05786f
C2765 VDD.n133 VSS 0.05964f
C2766 VDD.n134 VSS 0.12551f
C2767 VDD.t451 VSS 0.17202f
C2768 VDD.t452 VSS 0.17202f
C2769 VDD.n135 VSS 0.09116f
C2770 VDD.t218 VSS 0.14931f
C2771 VDD.t216 VSS 0.15196f
C2772 VDD.n136 VSS 0.05831f
C2773 VDD.t5 VSS 0.15196f
C2774 VDD.t183 VSS 0.14931f
C2775 VDD.n137 VSS 0.05786f
C2776 VDD.n138 VSS 0.09736f
C2777 VDD.n139 VSS 0.27395f
C2778 VDD.t50 VSS 0.06468f
C2779 VDD.t46 VSS 0.06571f
C2780 VDD.n140 VSS 0.05831f
C2781 VDD.t58 VSS 0.06468f
C2782 VDD.t54 VSS 0.06468f
C2783 VDD.n141 VSS 0.05786f
C2784 VDD.n142 VSS 0.02932f
C2785 VDD.t56 VSS 0.06468f
C2786 VDD.t60 VSS 0.06468f
C2787 VDD.n143 VSS 0.05786f
C2788 VDD.n144 VSS 0.0166f
C2789 VDD.t48 VSS 0.06571f
C2790 VDD.t52 VSS 0.06468f
C2791 VDD.n145 VSS 0.05786f
C2792 VDD.n146 VSS 0.16778f
C2793 VDD.t449 VSS 0.172f
C2794 VDD.t450 VSS 0.17203f
C2795 VDD.n147 VSS 0.07139f
C2796 VDD.n148 VSS 0.20709f
C2797 VDD.n149 VSS 0.11239f
C2798 VDD.n150 VSS 0.18565f
C2799 VDD.t163 VSS 0.06248f
C2800 VDD.t167 VSS 0.06152f
C2801 VDD.n151 VSS 0.05786f
C2802 VDD.n152 VSS 0.14328f
C2803 VDD.t161 VSS 0.06152f
C2804 VDD.t155 VSS 0.06248f
C2805 VDD.n153 VSS 0.05831f
C2806 VDD.t159 VSS 0.06152f
C2807 VDD.t165 VSS 0.06152f
C2808 VDD.n154 VSS 0.05786f
C2809 VDD.n155 VSS 0.02932f
C2810 VDD.t157 VSS 0.06152f
C2811 VDD.t169 VSS 0.06152f
C2812 VDD.n156 VSS 0.05786f
C2813 VDD.n157 VSS 0.01333f
C2814 VDD.n158 VSS 0.13991f
C2815 VDD.n159 VSS 0.17585f
C2816 VDD.t200 VSS 0.17352f
C2817 VDD.t201 VSS 0.17352f
C2818 VDD.n160 VSS 0.19367f
C2819 VDD.n161 VSS 0.24524f
C2820 VDD.n162 VSS 0.14854f
C2821 VDD.t341 VSS 0.08931f
C2822 VDD.t340 VSS 0.08931f
C2823 VDD.n163 VSS 0.05831f
C2824 VDD.t343 VSS 0.08931f
C2825 VDD.t342 VSS 0.08931f
C2826 VDD.n164 VSS 0.05786f
C2827 VDD.n165 VSS 0.02932f
C2828 VDD.t345 VSS 0.08931f
C2829 VDD.t344 VSS 0.08931f
C2830 VDD.n166 VSS 0.05786f
C2831 VDD.n167 VSS 0.0166f
C2832 VDD.t339 VSS 0.09081f
C2833 VDD.t346 VSS 0.08931f
C2834 VDD.n168 VSS 0.05786f
C2835 VDD.n169 VSS 0.0166f
C2836 VDD.n170 VSS 0.13538f
C2837 VDD.n171 VSS 0.14941f
C2838 VDD.n172 VSS 0.11575f
C2839 VDD.t334 VSS 0.09081f
C2840 VDD.t338 VSS 0.08931f
C2841 VDD.n173 VSS 0.05786f
C2842 VDD.n174 VSS 0.02585f
C2843 VDD.t336 VSS 0.08931f
C2844 VDD.t332 VSS 0.08931f
C2845 VDD.n175 VSS 0.05786f
C2846 VDD.n176 VSS 0.0166f
C2847 VDD.t330 VSS 0.08931f
C2848 VDD.t326 VSS 0.08931f
C2849 VDD.n177 VSS 0.05786f
C2850 VDD.n178 VSS 0.0166f
C2851 VDD.t324 VSS 0.08931f
C2852 VDD.t328 VSS 0.08931f
C2853 VDD.n179 VSS 0.05786f
C2854 VDD.n180 VSS 0.07771f
C2855 VDD.n181 VSS 0.08315f
C2856 VDD.n182 VSS 0.18589f
C2857 VDD.t230 VSS 0.16873f
C2858 VDD.t43 VSS 0.16876f
C2859 VDD.n183 VSS 0.1564f
C2860 VDD.n184 VSS 0.28023f
C2861 VDD.n185 VSS 0.09442f
C2862 VDD.t240 VSS 0.07574f
C2863 VDD.t249 VSS 0.07574f
C2864 VDD.n186 VSS 0.05831f
C2865 VDD.t250 VSS 0.07574f
C2866 VDD.t248 VSS 0.07574f
C2867 VDD.n187 VSS 0.05786f
C2868 VDD.n188 VSS 0.02932f
C2869 VDD.t252 VSS 0.07574f
C2870 VDD.t247 VSS 0.07574f
C2871 VDD.n189 VSS 0.05786f
C2872 VDD.n190 VSS 0.0166f
C2873 VDD.t253 VSS 0.07698f
C2874 VDD.t244 VSS 0.07574f
C2875 VDD.n191 VSS 0.05786f
C2876 VDD.n192 VSS 0.0166f
C2877 VDD.n193 VSS 0.10181f
C2878 VDD.n194 VSS 0.11536f
C2879 VDD.n195 VSS 0.07318f
C2880 VDD.t369 VSS 0.16875f
C2881 VDD.t228 VSS 0.16875f
C2882 VDD.n196 VSS 0.19367f
C2883 VDD.n197 VSS 0.27791f
C2884 VDD.n198 VSS 0.19219f
C2885 VDD.t423 VSS 0.06686f
C2886 VDD.t425 VSS 0.06581f
C2887 VDD.n199 VSS 0.05786f
C2888 VDD.n200 VSS 0.14328f
C2889 VDD.t411 VSS 0.06581f
C2890 VDD.t417 VSS 0.06686f
C2891 VDD.n201 VSS 0.05831f
C2892 VDD.t419 VSS 0.06581f
C2893 VDD.t415 VSS 0.06581f
C2894 VDD.n202 VSS 0.05786f
C2895 VDD.n203 VSS 0.02932f
C2896 VDD.t421 VSS 0.06581f
C2897 VDD.t413 VSS 0.06581f
C2898 VDD.n204 VSS 0.05786f
C2899 VDD.n205 VSS 0.01333f
C2900 VDD.n206 VSS 0.13991f
C2901 VDD.n207 VSS 0.17912f
C2902 VDD.n208 VSS 0.1798f
C2903 VDD.t134 VSS 0.0686f
C2904 VDD.t140 VSS 0.0697f
C2905 VDD.n209 VSS 0.05831f
C2906 VDD.t130 VSS 0.0686f
C2907 VDD.t136 VSS 0.0686f
C2908 VDD.n210 VSS 0.05786f
C2909 VDD.n211 VSS 0.02932f
C2910 VDD.t142 VSS 0.0686f
C2911 VDD.t138 VSS 0.0686f
C2912 VDD.n212 VSS 0.05786f
C2913 VDD.n213 VSS 0.0166f
C2914 VDD.t144 VSS 0.0697f
C2915 VDD.t132 VSS 0.0686f
C2916 VDD.n214 VSS 0.05786f
C2917 VDD.n215 VSS 0.16778f
C2918 VDD.t186 VSS 0.17305f
C2919 VDD.t187 VSS 0.17308f
C2920 VDD.n216 VSS 0.07139f
C2921 VDD.n217 VSS 0.20709f
C2922 VDD.n218 VSS 0.11565f
C2923 VDD.t236 VSS 0.14396f
C2924 VDD.t234 VSS 0.14651f
C2925 VDD.n219 VSS 0.05831f
C2926 VDD.t458 VSS 0.14651f
C2927 VDD.t22 VSS 0.14396f
C2928 VDD.n220 VSS 0.05786f
C2929 VDD.n221 VSS 0.08873f
C2930 VDD.n222 VSS 0.16524f
C2931 VDD.n223 VSS 15.6899f
C2932 VDD.n224 VSS 0.43625f
C2933 VDD.n225 VSS 0.10112f
C2934 VDD.n226 VSS 0.09672f
C2935 VDD.n227 VSS 0.43899f
C2936 VDD.t353 VSS 0.64483f
C2937 VDD.n228 VSS 0.09672f
C2938 VDD.n229 VSS 0.43625f
C2939 VDD.n230 VSS 0.43625f
C2940 VDD.n231 VSS 0.43625f
C2941 VDD.n232 VSS 0.10112f
C2942 VDD.n233 VSS 0.09672f
C2943 VDD.t355 VSS 0.51586f
C2944 VDD.t357 VSS 2.57931f
C2945 VDD.n234 VSS 5.72378f
C2946 VDD.t313 VSS 0.25793f
C2947 VDD.n235 VSS 0.27334f
C2948 VDD.t309 VSS 1.80552f
C2949 VDD.t359 VSS 2.32138f
C2950 VDD.n236 VSS 0.09672f
C2951 VDD.n237 VSS 0.09672f
C2952 VDD.n238 VSS 0.10112f
C2953 VDD.n239 VSS 0.43625f
C2954 VDD.t36 VSS 0.25793f
C2955 VDD.t295 VSS 0.25793f
C2956 VDD.t6 VSS 0.25793f
C2957 VDD.t303 VSS 0.25793f
C2958 VDD.t8 VSS 0.25793f
C2959 VDD.t299 VSS 0.25793f
C2960 VDD.t10 VSS 0.25793f
C2961 VDD.t301 VSS 0.90276f
C2962 VDD.t305 VSS 0.51586f
C2963 VDD.t307 VSS 0.51586f
C2964 VDD.t311 VSS 0.51586f
C2965 VDD.n240 VSS 2.45035f
C2966 VDD.t202 VSS 2.45035f
C2967 VDD.t437 VSS 0.51586f
C2968 VDD.t435 VSS 0.51586f
C2969 VDD.t433 VSS 0.51586f
C2970 VDD.n241 VSS 1.03172f
C2971 VDD.n242 VSS 0.09672f
C2972 VDD.n243 VSS 0.10112f
C2973 VDD.n244 VSS 0.43625f
C2974 VDD.n245 VSS 0.43625f
C2975 VDD.n246 VSS 0.43625f
C2976 VDD.n247 VSS 0.43625f
C2977 VDD.n248 VSS 0.43625f
C2978 VDD.n249 VSS 0.10112f
C2979 VDD.n250 VSS 0.09672f
C2980 VDD.t294 VSS 2.45035f
C2981 VDD.t293 VSS 0.51586f
C2982 VDD.t292 VSS 0.51586f
C2983 VDD.t291 VSS 0.3869f
C2984 VDD.n251 VSS 0.25793f
C2985 VDD.t290 VSS 0.3869f
C2986 VDD.t289 VSS 0.51586f
C2987 VDD.t288 VSS 0.51586f
C2988 VDD.t287 VSS 2.45035f
C2989 VDD.t394 VSS 2.32138f
C2990 VDD.t281 VSS 0.90276f
C2991 VDD.n252 VSS 0.09672f
C2992 VDD.n253 VSS 0.43625f
C2993 VDD.n254 VSS 0.43625f
C2994 VDD.n255 VSS 0.43625f
C2995 VDD.n256 VSS 0.43625f
C2996 VDD.n257 VSS 0.10112f
C2997 VDD.n258 VSS 0.09672f
C2998 VDD.t351 VSS 1.80552f
C2999 VDD.t0 VSS 0.25793f
C3000 VDD.t269 VSS 0.25793f
C3001 VDD.t400 VSS 0.25793f
C3002 VDD.t267 VSS 0.25793f
C3003 VDD.t402 VSS 0.25793f
C3004 VDD.t279 VSS 0.25793f
C3005 VDD.t404 VSS 0.25793f
C3006 VDD.t277 VSS 0.25793f
C3007 VDD.t469 VSS 0.51586f
C3008 VDD.t467 VSS 0.51586f
C3009 VDD.t465 VSS 1.16069f
C3010 VDD.n259 VSS 1.03172f
C3011 VDD.t273 VSS 0.3869f
C3012 VDD.t259 VSS 0.51586f
C3013 VDD.t261 VSS 0.51586f
C3014 VDD.t275 VSS 0.51586f
C3015 VDD.t271 VSS 0.3869f
C3016 VDD.n260 VSS 0.43619f
C3017 VDD.n261 VSS 0.27334f
C3018 VDD.n262 VSS 0.27334f
C3019 VDD.n263 VSS 4.5138f
C3020 VDD.n264 VSS 0.09672f
C3021 VDD.n265 VSS 0.43625f
C3022 VDD.n266 VSS 0.43625f
C3023 VDD.n267 VSS 0.37176f
C3024 VDD.n268 VSS 0.22066f
C3025 VDD.n269 VSS 0.10112f
C3026 VDD.n270 VSS 0.09672f
C3027 VDD.t448 VSS 0.12982f
C3028 VDD.t440 VSS 0.12759f
C3029 VDD.n271 VSS 0.05831f
C3030 VDD.t442 VSS 0.18719f
C3031 VDD.n272 VSS 0.16128f
C3032 VDD.n273 VSS 0.35928f
C3033 VDD.n274 VSS 0.15476f
C3034 VDD.t226 VSS 0.18799f
C3035 VDD.t473 VSS 0.18467f
C3036 VDD.n275 VSS 0.05831f
C3037 VDD.t475 VSS 0.18467f
C3038 VDD.t62 VSS 0.18467f
C3039 VDD.n276 VSS 0.05786f
C3040 VDD.n277 VSS 0.15432f
C3041 VDD.n278 VSS 0.23006f
C3042 VDD.n279 VSS 0.15476f
C3043 VDD.t106 VSS 0.10584f
C3044 VDD.t124 VSS 0.10584f
C3045 VDD.n280 VSS 0.05831f
C3046 VDD.t128 VSS 0.10584f
C3047 VDD.t126 VSS 0.10584f
C3048 VDD.n281 VSS 0.05786f
C3049 VDD.n282 VSS 0.02932f
C3050 VDD.t122 VSS 0.10584f
C3051 VDD.t104 VSS 0.10584f
C3052 VDD.n283 VSS 0.05786f
C3053 VDD.n284 VSS 0.0166f
C3054 VDD.t102 VSS 0.10584f
C3055 VDD.t110 VSS 0.10584f
C3056 VDD.n285 VSS 0.05786f
C3057 VDD.n286 VSS 0.0166f
C3058 VDD.t120 VSS 0.10584f
C3059 VDD.t108 VSS 0.10842f
C3060 VDD.n287 VSS 0.05786f
C3061 VDD.n288 VSS 0.22566f
C3062 VDD.n289 VSS 0.16296f
C3063 VDD.t64 VSS 0.18796f
C3064 VDD.t39 VSS 0.18799f
C3065 VDD.n290 VSS 0.12773f
C3066 VDD.n291 VSS 0.17344f
C3067 VDD.n292 VSS 0.15476f
C3068 VDD.t179 VSS 0.18599f
C3069 VDD.t181 VSS 0.18599f
C3070 VDD.n293 VSS 0.05797f
C3071 VDD.t146 VSS 0.18599f
C3072 VDD.t148 VSS 0.18934f
C3073 VDD.n294 VSS 0.05809f
C3074 VDD.n295 VSS 0.15442f
C3075 VDD.n296 VSS 0.21014f
C3076 VDD.t199 VSS 0.13686f
C3077 VDD.t460 VSS 0.1345f
C3078 VDD.n297 VSS 0.05831f
C3079 VDD.t462 VSS 0.1941f
C3080 VDD.n298 VSS 0.17042f
C3081 VDD.n299 VSS 0.71833f
C3082 VDD.t66 VSS 0.10842f
C3083 VDD.t72 VSS 0.10584f
C3084 VDD.n300 VSS 0.05831f
C3085 VDD.t84 VSS 0.10584f
C3086 VDD.t80 VSS 0.10584f
C3087 VDD.n301 VSS 0.05786f
C3088 VDD.n302 VSS 0.02932f
C3089 VDD.t82 VSS 0.10584f
C3090 VDD.t70 VSS 0.10584f
C3091 VDD.n303 VSS 0.05786f
C3092 VDD.n304 VSS 0.0166f
C3093 VDD.t76 VSS 0.10584f
C3094 VDD.t78 VSS 0.10584f
C3095 VDD.n305 VSS 0.05786f
C3096 VDD.n306 VSS 0.0166f
C3097 VDD.t74 VSS 0.10584f
C3098 VDD.t68 VSS 0.10584f
C3099 VDD.n307 VSS 0.05786f
C3100 VDD.n308 VSS 0.23797f
C3101 VDD.n309 VSS 0.17887f
C3102 VDD.t444 VSS 0.12982f
C3103 VDD.t446 VSS 0.12759f
C3104 VDD.n310 VSS 0.05831f
C3105 VDD.t454 VSS 0.12759f
C3106 VDD.t456 VSS 0.12759f
C3107 VDD.n311 VSS 0.05786f
C3108 VDD.n312 VSS 0.15432f
C3109 VDD.n313 VSS 0.26831f
C3110 VDD.n314 VSS 0.09235f
C3111 VDD.n315 VSS 0.52028f
C3112 VDD.n316 VSS 0.15476f
C3113 VDD.n317 VSS 0.02579f
C3114 VDD.t41 VSS 0.18799f
C3115 VDD.t18 VSS 0.18467f
C3116 VDD.n318 VSS 0.05831f
C3117 VDD.t20 VSS 0.18467f
C3118 VDD.t214 VSS 0.18467f
C3119 VDD.n319 VSS 0.05786f
C3120 VDD.n320 VSS 0.10254f
C3121 VDD.n321 VSS 0.14712f
C3122 VDD.n322 VSS 0.07093f
C3123 VDD.t86 VSS 0.14342f
C3124 VDD.t92 VSS 0.14093f
C3125 VDD.n323 VSS 0.05831f
C3126 VDD.t90 VSS 0.14093f
C3127 VDD.t88 VSS 0.14093f
C3128 VDD.n324 VSS 0.05786f
C3129 VDD.n325 VSS 0.12466f
C3130 VDD.n326 VSS 0.17615f
C3131 VDD.n327 VSS 0.07093f
C3132 VDD.n328 VSS 0.15476f
C3133 VDD.n329 VSS 0.15476f
C3134 VDD.n330 VSS 0.10317f
C3135 VDD.t391 VSS 0.18934f
C3136 VDD.t393 VSS 0.18931f
C3137 VDD.n331 VSS 0.12549f
C3138 VDD.n332 VSS 0.17241f
C3139 VDD.n333 VSS 0.05803f
C3140 VDD.t118 VSS 0.14342f
C3141 VDD.t116 VSS 0.14093f
C3142 VDD.n334 VSS 0.05831f
C3143 VDD.t114 VSS 0.14093f
C3144 VDD.t112 VSS 0.14093f
C3145 VDD.n335 VSS 0.05786f
C3146 VDD.n336 VSS 0.12466f
C3147 VDD.n337 VSS 0.171f
C3148 VDD.t381 VSS 0.18934f
C3149 VDD.t383 VSS 0.18599f
C3150 VDD.n338 VSS 0.05831f
C3151 VDD.t385 VSS 0.18599f
C3152 VDD.t387 VSS 0.18599f
C3153 VDD.n339 VSS 0.05786f
C3154 VDD.n340 VSS 0.095f
C3155 VDD.n341 VSS 0.13875f
C3156 VDD.n342 VSS 0.05206f
C3157 VDD.n343 VSS 0.15476f
C3158 VDD.n344 VSS 0.15476f
C3159 VDD.n345 VSS 0.06448f
C3160 VDD.t389 VSS 0.1345f
C3161 VDD.t210 VSS 0.1345f
C3162 VDD.n346 VSS 0.05831f
C3163 VDD.t212 VSS 0.1345f
C3164 VDD.t197 VSS 0.13686f
C3165 VDD.n347 VSS 0.05786f
C3166 VDD.n348 VSS 0.15432f
C3167 VDD.n349 VSS 0.20582f
C3168 VDD.n350 VSS 0.13412f
C3169 VDD.n351 VSS 0.09157f
C3170 VDD.n352 VSS 0.20543f
C3171 VDD.n353 VSS 0.16181f
C3172 VDD.n354 VSS 0.16806f
C3173 VDD.n355 VSS 0.19707f
C3174 VDD.t447 VSS 0.64483f
C3175 VDD.n356 VSS 0.09672f
C3176 VDD.n357 VSS 0.37176f
C3177 VDD.n358 VSS 0.43625f
C3178 VDD.n359 VSS 0.43625f
C3179 VDD.n360 VSS 0.43625f
C3180 VDD.n361 VSS 0.10112f
C3181 VDD.n362 VSS 0.09672f
C3182 VDD.t439 VSS 0.51586f
C3183 VDD.t441 VSS 2.57931f
C3184 VDD.n363 VSS 5.72378f
C3185 VDD.t103 VSS 0.25793f
C3186 VDD.n364 VSS 0.27334f
C3187 VDD.n365 VSS 0.27334f
C3188 VDD.t111 VSS 1.80552f
C3189 VDD.t392 VSS 2.32138f
C3190 VDD.n366 VSS 0.09672f
C3191 VDD.n367 VSS 0.09672f
C3192 VDD.n368 VSS 0.10112f
C3193 VDD.n369 VSS 0.43625f
C3194 VDD.t225 VSS 0.25793f
C3195 VDD.t101 VSS 0.25793f
C3196 VDD.t472 VSS 0.25793f
C3197 VDD.t109 VSS 0.25793f
C3198 VDD.t474 VSS 0.25793f
C3199 VDD.t119 VSS 0.25793f
C3200 VDD.t61 VSS 0.25793f
C3201 VDD.t107 VSS 0.90276f
C3202 VDD.t113 VSS 0.51586f
C3203 VDD.t115 VSS 0.51586f
C3204 VDD.t117 VSS 0.51586f
C3205 VDD.n370 VSS 2.45035f
C3206 VDD.t386 VSS 2.45035f
C3207 VDD.t384 VSS 0.51586f
C3208 VDD.t382 VSS 0.51586f
C3209 VDD.t380 VSS 0.51586f
C3210 VDD.n371 VSS 1.03172f
C3211 VDD.n372 VSS 0.09672f
C3212 VDD.n373 VSS 0.10112f
C3213 VDD.n374 VSS 0.43625f
C3214 VDD.n375 VSS 0.43625f
C3215 VDD.n376 VSS 0.43625f
C3216 VDD.n377 VSS 0.43625f
C3217 VDD.n378 VSS 0.43625f
C3218 VDD.n379 VSS 0.10112f
C3219 VDD.n380 VSS 0.09672f
C3220 VDD.t100 VSS 2.45035f
C3221 VDD.t99 VSS 0.51586f
C3222 VDD.t98 VSS 0.51586f
C3223 VDD.t97 VSS 0.3869f
C3224 VDD.n381 VSS 0.25793f
C3225 VDD.t96 VSS 0.3869f
C3226 VDD.t95 VSS 0.51586f
C3227 VDD.t94 VSS 0.51586f
C3228 VDD.t93 VSS 2.45035f
C3229 VDD.t63 VSS 2.32138f
C3230 VDD.t65 VSS 0.90276f
C3231 VDD.n382 VSS 0.09672f
C3232 VDD.n383 VSS 0.43625f
C3233 VDD.n384 VSS 0.43625f
C3234 VDD.n385 VSS 0.43625f
C3235 VDD.n386 VSS 0.43625f
C3236 VDD.n387 VSS 0.10112f
C3237 VDD.n388 VSS 0.09672f
C3238 VDD.t455 VSS 1.80552f
C3239 VDD.t178 VSS 0.25793f
C3240 VDD.t71 VSS 0.25793f
C3241 VDD.t180 VSS 0.25793f
C3242 VDD.t83 VSS 0.25793f
C3243 VDD.t145 VSS 0.25793f
C3244 VDD.t79 VSS 0.25793f
C3245 VDD.t147 VSS 0.25793f
C3246 VDD.t81 VSS 0.25793f
C3247 VDD.t453 VSS 0.51586f
C3248 VDD.t445 VSS 0.51586f
C3249 VDD.t443 VSS 1.16069f
C3250 VDD.n389 VSS 1.03172f
C3251 VDD.t67 VSS 0.3869f
C3252 VDD.t73 VSS 0.51586f
C3253 VDD.t77 VSS 0.51586f
C3254 VDD.t75 VSS 0.51586f
C3255 VDD.t69 VSS 0.3869f
C3256 VDD.n390 VSS 0.43619f
C3257 VDD.n391 VSS 0.27334f
C3258 VDD.n392 VSS 0.439f
C3259 VDD.n393 VSS 4.5138f
C3260 VDD.n394 VSS 0.09672f
C3261 VDD.n395 VSS 0.43625f
C3262 VDD.n396 VSS 0.43625f
C3263 VDD.n397 VSS 0.43625f
C3264 VDD.n398 VSS 14.4914f
C3265 VDD.n399 VSS 0.93062f
C3266 VDD.n400 VSS 3.72091f
C3267 VDD.n401 VSS 4.93027f
C3268 VDD.n402 VSS 0.08177f
C3269 VDD.n403 VSS 0.10112f
C3270 VDD.n404 VSS 0.10112f
C3271 VDD.n405 VSS 0.09672f
C3272 VDD.n406 VSS 3.61104f
C3273 VDD.t461 VSS 0.64483f
C3274 VDD.t459 VSS 0.51586f
C3275 VDD.t198 VSS 2.57931f
C3276 VDD.n407 VSS 5.72378f
C3277 VDD.n408 VSS 4.77173f
C3278 VDD.n409 VSS 0.09672f
C3279 VDD.n410 VSS 0.10112f
C3280 VDD.n411 VSS 0.10112f
C3281 VDD.n412 VSS 0.10112f
C3282 VDD.n413 VSS 0.09672f
C3283 VDD.n414 VSS 1.03172f
C3284 VDD.t213 VSS 0.51586f
C3285 VDD.t19 VSS 0.51586f
C3286 VDD.t17 VSS 0.51586f
C3287 VDD.t40 VSS 2.45035f
C3288 VDD.n415 VSS 2.45035f
C3289 VDD.t87 VSS 0.51586f
C3290 VDD.t89 VSS 0.51586f
C3291 VDD.t91 VSS 0.51586f
C3292 VDD.t85 VSS 1.80552f
C3293 VDD.n416 VSS 2.24171f
C3294 VDD.t38 VSS 0.64483f
C3295 VDD.n417 VSS 0.25793f
C3296 VDD.n418 VSS 0.09672f
C3297 VDD.n419 VSS 0.10112f
C3298 VDD.n420 VSS 0.10112f
C3299 VDD.n421 VSS 0.10112f
C3300 VDD.n422 VSS 0.09672f
C3301 VDD.n423 VSS 0.25793f
C3302 VDD.t390 VSS 0.64483f
C3303 VDD.n424 VSS 2.24171f
C3304 VDD.n425 VSS 0.27334f
C3305 VDD.n426 VSS 0.27334f
C3306 VDD.n427 VSS 0.43619f
C3307 VDD.t121 VSS 0.3869f
C3308 VDD.t125 VSS 0.51586f
C3309 VDD.t127 VSS 0.51586f
C3310 VDD.t123 VSS 0.51586f
C3311 VDD.t105 VSS 0.3869f
C3312 VDD.n428 VSS 1.03172f
C3313 VDD.t196 VSS 1.16069f
C3314 VDD.t211 VSS 0.51586f
C3315 VDD.t209 VSS 0.51586f
C3316 VDD.t388 VSS 1.80552f
C3317 VDD.n429 VSS 4.77173f
C3318 VDD.n430 VSS 0.09672f
C3319 VDD.n431 VSS 0.10112f
C3320 VDD.n432 VSS 0.10112f
C3321 VDD.n433 VSS 0.10112f
C3322 VDD.n434 VSS 0.09672f
C3323 VDD.n435 VSS 3.61104f
C3324 VDD.n436 VSS 4.5138f
C3325 VDD.n437 VSS 3.70814f
C3326 VDD.n438 VSS 4.93027f
C3327 VDD.n439 VSS 0.08177f
C3328 VDD.n440 VSS 1.27452f
C3329 VDD.n441 VSS 1.27452f
C3330 VDD.n442 VSS 0.20543f
C3331 VDD.t466 VSS 0.13686f
C3332 VDD.t468 VSS 0.1345f
C3333 VDD.n443 VSS 0.05786f
C3334 VDD.t470 VSS 0.1345f
C3335 VDD.t352 VSS 0.1345f
C3336 VDD.n444 VSS 0.05831f
C3337 VDD.n445 VSS 0.15432f
C3338 VDD.n446 VSS 0.20582f
C3339 VDD.n447 VSS 0.15476f
C3340 VDD.t395 VSS 0.18931f
C3341 VDD.t397 VSS 0.18934f
C3342 VDD.n448 VSS 0.12549f
C3343 VDD.n449 VSS 0.17241f
C3344 VDD.n450 VSS 0.15476f
C3345 VDD.t438 VSS 0.18467f
C3346 VDD.t203 VSS 0.18799f
C3347 VDD.n451 VSS 0.05831f
C3348 VDD.t434 VSS 0.18467f
C3349 VDD.t436 VSS 0.18467f
C3350 VDD.n452 VSS 0.05786f
C3351 VDD.n453 VSS 0.10254f
C3352 VDD.n454 VSS 0.14712f
C3353 VDD.n455 VSS 0.52027f
C3354 VDD.t356 VSS 0.1345f
C3355 VDD.t358 VSS 0.13686f
C3356 VDD.n456 VSS 0.05831f
C3357 VDD.t354 VSS 0.1941f
C3358 VDD.n457 VSS 0.17042f
C3359 VDD.n458 VSS 0.71835f
C3360 VDD.t377 VSS 0.12759f
C3361 VDD.t379 VSS 0.12759f
C3362 VDD.n459 VSS 0.05786f
C3363 VDD.t371 VSS 0.12759f
C3364 VDD.t373 VSS 0.12982f
C3365 VDD.n460 VSS 0.05831f
C3366 VDD.n461 VSS 0.15432f
C3367 VDD.n462 VSS 0.26831f
C3368 VDD.n463 VSS 0.09235f
C3369 VDD.t300 VSS 0.10584f
C3370 VDD.t302 VSS 0.10842f
C3371 VDD.n464 VSS 0.05831f
C3372 VDD.t296 VSS 0.10584f
C3373 VDD.t304 VSS 0.10584f
C3374 VDD.n465 VSS 0.05786f
C3375 VDD.n466 VSS 0.02932f
C3376 VDD.t320 VSS 0.10584f
C3377 VDD.t314 VSS 0.10584f
C3378 VDD.n467 VSS 0.05786f
C3379 VDD.n468 VSS 0.0166f
C3380 VDD.t316 VSS 0.10584f
C3381 VDD.t318 VSS 0.10584f
C3382 VDD.n469 VSS 0.05786f
C3383 VDD.n470 VSS 0.0166f
C3384 VDD.t322 VSS 0.10584f
C3385 VDD.t298 VSS 0.10584f
C3386 VDD.n471 VSS 0.05786f
C3387 VDD.n472 VSS 0.23797f
C3388 VDD.n473 VSS 0.17887f
C3389 VDD.t37 VSS 0.18934f
C3390 VDD.t7 VSS 0.18599f
C3391 VDD.n474 VSS 0.05809f
C3392 VDD.t9 VSS 0.18599f
C3393 VDD.t11 VSS 0.18599f
C3394 VDD.n475 VSS 0.05797f
C3395 VDD.n476 VSS 0.15442f
C3396 VDD.n477 VSS 0.21014f
C3397 VDD.n478 VSS 0.02579f
C3398 VDD.n479 VSS 0.15476f
C3399 VDD.n480 VSS 0.15476f
C3400 VDD.n481 VSS 0.07093f
C3401 VDD.t312 VSS 0.14093f
C3402 VDD.t308 VSS 0.14093f
C3403 VDD.n482 VSS 0.05786f
C3404 VDD.t306 VSS 0.14093f
C3405 VDD.t310 VSS 0.14342f
C3406 VDD.n483 VSS 0.05831f
C3407 VDD.n484 VSS 0.12466f
C3408 VDD.n485 VSS 0.17615f
C3409 VDD.n486 VSS 0.07093f
C3410 VDD.t205 VSS 0.18799f
C3411 VDD.t360 VSS 0.18796f
C3412 VDD.n487 VSS 0.12773f
C3413 VDD.n488 VSS 0.17344f
C3414 VDD.n489 VSS 0.10317f
C3415 VDD.n490 VSS 0.15476f
C3416 VDD.n491 VSS 0.15476f
C3417 VDD.n492 VSS 0.05803f
C3418 VDD.t286 VSS 0.14093f
C3419 VDD.t266 VSS 0.14093f
C3420 VDD.n493 VSS 0.05786f
C3421 VDD.t284 VSS 0.14093f
C3422 VDD.t264 VSS 0.14342f
C3423 VDD.n494 VSS 0.05831f
C3424 VDD.n495 VSS 0.12466f
C3425 VDD.n496 VSS 0.171f
C3426 VDD.t399 VSS 0.18599f
C3427 VDD.t220 VSS 0.18599f
C3428 VDD.n497 VSS 0.05786f
C3429 VDD.t222 VSS 0.18599f
C3430 VDD.t464 VSS 0.18934f
C3431 VDD.n498 VSS 0.05831f
C3432 VDD.n499 VSS 0.095f
C3433 VDD.n500 VSS 0.13875f
C3434 VDD.n501 VSS 0.05206f
C3435 VDD.t260 VSS 0.10584f
C3436 VDD.t274 VSS 0.10584f
C3437 VDD.n502 VSS 0.05831f
C3438 VDD.t276 VSS 0.10584f
C3439 VDD.t262 VSS 0.10584f
C3440 VDD.n503 VSS 0.05786f
C3441 VDD.n504 VSS 0.02932f
C3442 VDD.t278 VSS 0.10584f
C3443 VDD.t272 VSS 0.10584f
C3444 VDD.n505 VSS 0.05786f
C3445 VDD.n506 VSS 0.0166f
C3446 VDD.t268 VSS 0.10584f
C3447 VDD.t280 VSS 0.10584f
C3448 VDD.n507 VSS 0.05786f
C3449 VDD.n508 VSS 0.0166f
C3450 VDD.t282 VSS 0.10842f
C3451 VDD.t270 VSS 0.10584f
C3452 VDD.n509 VSS 0.05786f
C3453 VDD.n510 VSS 0.22566f
C3454 VDD.n511 VSS 0.16296f
C3455 VDD.t1 VSS 0.18467f
C3456 VDD.t401 VSS 0.18467f
C3457 VDD.n512 VSS 0.05786f
C3458 VDD.t403 VSS 0.18467f
C3459 VDD.t405 VSS 0.18799f
C3460 VDD.n513 VSS 0.05831f
C3461 VDD.n514 VSS 0.15432f
C3462 VDD.n515 VSS 0.23006f
C3463 VDD.n516 VSS 0.06448f
C3464 VDD.n517 VSS 0.15476f
C3465 VDD.n518 VSS 0.15476f
C3466 VDD.n519 VSS 0.13412f
C3467 VDD.n520 VSS 0.09157f
C3468 VDD.t191 VSS 0.12759f
C3469 VDD.t193 VSS 0.12982f
C3470 VDD.n521 VSS 0.05831f
C3471 VDD.t375 VSS 0.18719f
C3472 VDD.n522 VSS 0.16128f
C3473 VDD.n523 VSS 0.35928f
C3474 VDD.n524 VSS 0.16181f
C3475 VDD.n525 VSS 0.22066f
C3476 VDD.n526 VSS 0.16806f
C3477 VDD.n527 VSS 0.19708f
C3478 VDD.n528 VSS 3.70813f
C3479 VDD.n529 VSS 4.93027f
C3480 VDD.n530 VSS 0.08177f
C3481 VDD.n531 VSS 0.10112f
C3482 VDD.n532 VSS 0.10112f
C3483 VDD.n533 VSS 0.09672f
C3484 VDD.n534 VSS 3.61104f
C3485 VDD.t192 VSS 0.64483f
C3486 VDD.t190 VSS 0.51586f
C3487 VDD.t374 VSS 2.57931f
C3488 VDD.n535 VSS 5.72378f
C3489 VDD.n536 VSS 4.77173f
C3490 VDD.n537 VSS 0.09672f
C3491 VDD.n538 VSS 0.10112f
C3492 VDD.n539 VSS 0.10112f
C3493 VDD.n540 VSS 0.10112f
C3494 VDD.n541 VSS 0.09672f
C3495 VDD.n542 VSS 1.03172f
C3496 VDD.t463 VSS 0.51586f
C3497 VDD.t221 VSS 0.51586f
C3498 VDD.t219 VSS 0.51586f
C3499 VDD.t398 VSS 2.45035f
C3500 VDD.n543 VSS 2.45035f
C3501 VDD.t263 VSS 0.51586f
C3502 VDD.t283 VSS 0.51586f
C3503 VDD.t265 VSS 0.51586f
C3504 VDD.t285 VSS 1.80552f
C3505 VDD.n544 VSS 2.24171f
C3506 VDD.t396 VSS 0.64483f
C3507 VDD.n545 VSS 0.25793f
C3508 VDD.n546 VSS 0.09672f
C3509 VDD.n547 VSS 0.10112f
C3510 VDD.n548 VSS 0.10112f
C3511 VDD.n549 VSS 0.10112f
C3512 VDD.n550 VSS 0.09672f
C3513 VDD.n551 VSS 0.25793f
C3514 VDD.t204 VSS 0.64483f
C3515 VDD.n552 VSS 2.24171f
C3516 VDD.n553 VSS 0.27334f
C3517 VDD.n554 VSS 0.27334f
C3518 VDD.n555 VSS 0.43619f
C3519 VDD.t319 VSS 0.3869f
C3520 VDD.t317 VSS 0.51586f
C3521 VDD.t315 VSS 0.51586f
C3522 VDD.t297 VSS 0.51586f
C3523 VDD.t321 VSS 0.3869f
C3524 VDD.n556 VSS 1.03172f
C3525 VDD.t372 VSS 1.16069f
C3526 VDD.t370 VSS 0.51586f
C3527 VDD.t378 VSS 0.51586f
C3528 VDD.t376 VSS 1.80552f
C3529 VDD.n557 VSS 4.77173f
C3530 VDD.n558 VSS 0.09672f
C3531 VDD.n559 VSS 0.10112f
C3532 VDD.n560 VSS 0.10112f
C3533 VDD.n561 VSS 0.10112f
C3534 VDD.n562 VSS 0.09672f
C3535 VDD.n563 VSS 3.61104f
C3536 VDD.n564 VSS 4.5138f
C3537 VDD.n565 VSS 3.72091f
C3538 VDD.n566 VSS 4.93027f
C3539 VDD.n567 VSS 0.08177f
C3540 VDD.n568 VSS 0.93062f
C3541 VDD.n569 VSS 13.4742f
C3542 VDD.n570 VSS 22.6061f
C3543 VDD.n571 VSS 14.4564f
C3544 E_CAPTURE_CLKB.n0 VSS 0.04313f
C3545 E_CAPTURE_CLKB.n1 VSS 0.04313f
C3546 E_CAPTURE_CLKB.n2 VSS 0.04313f
C3547 E_CAPTURE_CLKB.n3 VSS 0.04313f
C3548 E_CAPTURE_CLKB.n4 VSS 0.12555f
C3549 E_CAPTURE_CLKB.n5 VSS 0.06206f
C3550 E_CAPTURE_CLKB.n6 VSS 0.06652f
C3551 E_CAPTURE_CLKB.n7 VSS 0.06652f
C3552 E_CAPTURE_CLKB.n8 VSS 0.06652f
C3553 E_CAPTURE_CLKB.n9 VSS 0.06652f
C3554 E_CAPTURE_CLKB.n10 VSS 0.06652f
C3555 E_CAPTURE_CLKB.n11 VSS 0.06652f
C3556 E_CAPTURE_CLKB.n12 VSS 0.06287f
C3557 E_CAPTURE_CLKB.n13 VSS 0.27389f
C3558 E_CAPTURE_CLKB.n14 VSS 0.04313f
C3559 E_CAPTURE_CLKB.n15 VSS 0.06652f
C3560 E_CAPTURE_CLKB.n16 VSS 0.12555f
C3561 E_CAPTURE_CLKB.n17 VSS 0.06206f
C3562 E_CAPTURE_CLKB.n18 VSS 0.06652f
C3563 E_CAPTURE_CLKB.n19 VSS 0.06652f
C3564 E_CAPTURE_CLKB.n20 VSS 0.06652f
C3565 E_CAPTURE_CLKB.n21 VSS 0.04313f
C3566 E_CAPTURE_CLKB.n22 VSS 0.04313f
C3567 E_CAPTURE_CLKB.n23 VSS 0.04313f
C3568 E_CAPTURE_CLKB.n24 VSS 0.06652f
C3569 E_CAPTURE_CLKB.n25 VSS 0.06652f
C3570 E_CAPTURE_CLKB.n26 VSS 0.06287f
C3571 E_CAPTURE_CLKB.n27 VSS 0.11034f
C3572 E_CAPTURE_CLKB.n28 VSS 9.37357f
C3573 O_CAPTURE_CLKB.n0 VSS 0.0522f
C3574 O_CAPTURE_CLKB.n1 VSS 0.0522f
C3575 O_CAPTURE_CLKB.n2 VSS 0.0522f
C3576 O_CAPTURE_CLKB.n3 VSS 0.0522f
C3577 O_CAPTURE_CLKB.n4 VSS 0.15194f
C3578 O_CAPTURE_CLKB.n5 VSS 0.0751f
C3579 O_CAPTURE_CLKB.n6 VSS 0.0805f
C3580 O_CAPTURE_CLKB.n7 VSS 0.0805f
C3581 O_CAPTURE_CLKB.n8 VSS 0.0805f
C3582 O_CAPTURE_CLKB.n9 VSS 0.0805f
C3583 O_CAPTURE_CLKB.n10 VSS 0.0805f
C3584 O_CAPTURE_CLKB.n11 VSS 0.0805f
C3585 O_CAPTURE_CLKB.n12 VSS 0.07608f
C3586 O_CAPTURE_CLKB.n13 VSS 0.33148f
C3587 O_CAPTURE_CLKB.n14 VSS 0.0522f
C3588 O_CAPTURE_CLKB.n15 VSS 0.0805f
C3589 O_CAPTURE_CLKB.n16 VSS 0.15194f
C3590 O_CAPTURE_CLKB.n17 VSS 0.0751f
C3591 O_CAPTURE_CLKB.n18 VSS 0.0805f
C3592 O_CAPTURE_CLKB.n19 VSS 0.0805f
C3593 O_CAPTURE_CLKB.n20 VSS 0.0805f
C3594 O_CAPTURE_CLKB.n21 VSS 0.0522f
C3595 O_CAPTURE_CLKB.n22 VSS 0.0522f
C3596 O_CAPTURE_CLKB.n23 VSS 0.0522f
C3597 O_CAPTURE_CLKB.n24 VSS 0.0805f
C3598 O_CAPTURE_CLKB.n25 VSS 0.0805f
C3599 O_CAPTURE_CLKB.n26 VSS 0.07608f
C3600 O_CAPTURE_CLKB.n27 VSS 0.13354f
C3601 O_CAPTURE_CLKB.n28 VSS 9.47976f
C3602 EVEN_Q.t6 VSS 1.30833f
C3603 EVEN_Q.t1 VSS 0.31666f
C3604 EVEN_Q.t4 VSS 0.31666f
C3605 EVEN_Q.n0 VSS 0.95179f
C3606 EVEN_Q.n1 VSS 0.46942f
C3607 EVEN_Q.t3 VSS 1.30323f
C3608 EVEN_Q.n2 VSS 1.50424f
C3609 EVEN_Q.t5 VSS 0.31666f
C3610 EVEN_Q.t0 VSS 0.31666f
C3611 EVEN_Q.n3 VSS 0.94983f
C3612 EVEN_Q.t2 VSS 1.29902f
C3613 EVEN_Q.n4 VSS 0.478f
C3614 EVEN_Q.n5 VSS 2.99553f
C3615 EVEN_QB.t3 VSS 1.23849f
C3616 EVEN_QB.t4 VSS 0.30028f
C3617 EVEN_QB.t2 VSS 0.30028f
C3618 EVEN_QB.n0 VSS 0.90047f
C3619 EVEN_QB.n1 VSS 0.44411f
C3620 EVEN_QB.t1 VSS 1.23367f
C3621 EVEN_QB.n2 VSS 1.42314f
C3622 EVEN_QB.t6 VSS 0.30028f
C3623 EVEN_QB.t5 VSS 0.30028f
C3624 EVEN_QB.n3 VSS 0.89862f
C3625 EVEN_QB.t0 VSS 1.22968f
C3626 EVEN_QB.n4 VSS 0.45223f
C3627 EVEN_QB.n5 VSS 4.71698f
C3628 ODD_QB.t4 VSS 1.12327f
C3629 ODD_QB.t3 VSS 0.28473f
C3630 ODD_QB.t6 VSS 0.28473f
C3631 ODD_QB.n0 VSS 0.8045f
C3632 ODD_QB.n1 VSS 0.39678f
C3633 ODD_QB.t1 VSS 1.11896f
C3634 ODD_QB.n2 VSS 1.21079f
C3635 ODD_QB.t2 VSS 0.28473f
C3636 ODD_QB.t5 VSS 0.28473f
C3637 ODD_QB.n3 VSS 0.80285f
C3638 ODD_QB.t0 VSS 1.1154f
C3639 ODD_QB.n4 VSS 0.41162f
C3640 ODD_QB.n5 VSS 4.3519f
C3641 ODD_Q.t1 VSS 1.33923f
C3642 ODD_Q.t4 VSS 0.326f
C3643 ODD_Q.t6 VSS 0.326f
C3644 ODD_Q.n0 VSS 0.97244f
C3645 ODD_Q.n1 VSS 0.47961f
C3646 ODD_Q.t5 VSS 1.33402f
C3647 ODD_Q.n2 VSS 1.51482f
C3648 ODD_Q.t3 VSS 0.326f
C3649 ODD_Q.t0 VSS 0.326f
C3650 ODD_Q.n3 VSS 0.97044f
C3651 ODD_Q.t2 VSS 1.32972f
C3652 ODD_Q.n4 VSS 0.48981f
C3653 ODD_Q.n5 VSS 2.90226f
C3654 FE_E_N.n0 VSS 0.03233f
C3655 FE_E_N.n1 VSS 0.11167f
C3656 FE_E_N.n2 VSS 0.0552f
C3657 FE_E_N.n3 VSS 0.05916f
C3658 FE_E_N.n4 VSS 0.05916f
C3659 FE_E_N.n5 VSS 0.11167f
C3660 FE_E_N.n6 VSS 0.0552f
C3661 FE_E_N.n7 VSS 0.05916f
C3662 FE_E_N.n8 VSS 0.05916f
C3663 FE_E_N.n9 VSS 0.05916f
C3664 FE_E_N.n10 VSS 0.05916f
C3665 FE_E_N.n11 VSS 0.03233f
C3666 FE_E_N.n12 VSS 0.21097f
C3667 FE_E_N.n13 VSS 0.05441f
C3668 FE_E_N.n14 VSS 0.05916f
C3669 FE_E_N.n15 VSS 0.05916f
C3670 FE_E_N.n16 VSS 0.05441f
C3671 FE_E_N.n17 VSS 0.16294f
C3672 FE_E_N.n18 VSS 6.51504f
C3673 FE_E_N.t6 VSS 0.54906f
C3674 FE_E_N.t2 VSS 0.18396f
C3675 FE_E_N.t3 VSS 0.18396f
C3676 FE_E_N.n19 VSS 0.34988f
C3677 FE_E_N.n20 VSS 0.32674f
C3678 FE_E_N.t0 VSS 0.54465f
C3679 FE_E_N.t5 VSS 0.54875f
C3680 FE_E_N.t1 VSS 0.18396f
C3681 FE_E_N.t4 VSS 0.18396f
C3682 FE_E_N.n21 VSS 0.3471f
C3683 FE_E_N.n22 VSS 0.17587f
C3684 FE_E_N.n23 VSS 0.23922f
C3685 FE_E_N.n24 VSS 0.79535f
C3686 FE_E_N.n25 VSS 6.37414f
C3687 FE_E_P.n0 VSS 0.03076f
C3688 FE_E_P.n1 VSS 0.10625f
C3689 FE_E_P.n2 VSS 0.05252f
C3690 FE_E_P.n3 VSS 0.05629f
C3691 FE_E_P.n4 VSS 0.05629f
C3692 FE_E_P.n5 VSS 0.10625f
C3693 FE_E_P.n6 VSS 0.05252f
C3694 FE_E_P.n7 VSS 0.05629f
C3695 FE_E_P.n8 VSS 0.05629f
C3696 FE_E_P.n9 VSS 0.05629f
C3697 FE_E_P.n10 VSS 0.05629f
C3698 FE_E_P.n11 VSS 0.03076f
C3699 FE_E_P.n12 VSS 0.20073f
C3700 FE_E_P.n13 VSS 0.05177f
C3701 FE_E_P.n14 VSS 0.05629f
C3702 FE_E_P.n15 VSS 0.05629f
C3703 FE_E_P.n16 VSS 0.05177f
C3704 FE_E_P.n17 VSS 0.15503f
C3705 FE_E_P.n18 VSS 6.57164f
C3706 FE_E_P.t0 VSS 0.53077f
C3707 FE_E_P.t4 VSS 0.53491f
C3708 FE_E_P.t2 VSS 0.18759f
C3709 FE_E_P.t3 VSS 0.18759f
C3710 FE_E_P.n19 VSS 0.33025f
C3711 FE_E_P.n20 VSS 0.16734f
C3712 FE_E_P.n21 VSS 0.25043f
C3713 FE_E_P.t1 VSS 0.53521f
C3714 FE_E_P.t5 VSS 0.18759f
C3715 FE_E_P.t6 VSS 0.18759f
C3716 FE_E_P.n22 VSS 0.33289f
C3717 FE_E_P.n23 VSS 0.28798f
C3718 FE_E_P.n24 VSS 0.76795f
C3719 FE_O_P.n0 VSS 0.02834f
C3720 FE_O_P.n1 VSS 0.09789f
C3721 FE_O_P.n2 VSS 0.04839f
C3722 FE_O_P.n3 VSS 0.05186f
C3723 FE_O_P.n4 VSS 0.05186f
C3724 FE_O_P.n5 VSS 0.09789f
C3725 FE_O_P.n6 VSS 0.04839f
C3726 FE_O_P.n7 VSS 0.05186f
C3727 FE_O_P.n8 VSS 0.05186f
C3728 FE_O_P.n9 VSS 0.05186f
C3729 FE_O_P.n10 VSS 0.05186f
C3730 FE_O_P.n11 VSS 0.02834f
C3731 FE_O_P.n12 VSS 0.18494f
C3732 FE_O_P.n13 VSS 0.0477f
C3733 FE_O_P.n14 VSS 0.05186f
C3734 FE_O_P.n15 VSS 0.05186f
C3735 FE_O_P.n16 VSS 0.0477f
C3736 FE_O_P.n17 VSS 0.14284f
C3737 FE_O_P.n18 VSS 4.64102f
C3738 FE_O_P.t2 VSS 0.17563f
C3739 FE_O_P.t0 VSS 0.17563f
C3740 FE_O_P.n19 VSS 0.30671f
C3741 FE_O_P.t1 VSS 0.49596f
C3742 FE_O_P.n20 VSS 0.28643f
C3743 FE_O_P.t5 VSS 0.49569f
C3744 FE_O_P.t6 VSS 0.17563f
C3745 FE_O_P.t3 VSS 0.17563f
C3746 FE_O_P.n21 VSS 0.30427f
C3747 FE_O_P.n22 VSS 0.15417f
C3748 FE_O_P.t4 VSS 0.49181f
C3749 FE_O_P.n23 VSS 0.20971f
C3750 FE_O_P.n24 VSS 0.69763f
C3751 FE_O_N.n0 VSS 0.03012f
C3752 FE_O_N.n1 VSS 0.10404f
C3753 FE_O_N.n2 VSS 0.05143f
C3754 FE_O_N.n3 VSS 0.05512f
C3755 FE_O_N.n4 VSS 0.05512f
C3756 FE_O_N.n5 VSS 0.10404f
C3757 FE_O_N.n6 VSS 0.05143f
C3758 FE_O_N.n7 VSS 0.05512f
C3759 FE_O_N.n8 VSS 0.05512f
C3760 FE_O_N.n9 VSS 0.05512f
C3761 FE_O_N.n10 VSS 0.05512f
C3762 FE_O_N.n11 VSS 0.03012f
C3763 FE_O_N.n12 VSS 0.19656f
C3764 FE_O_N.n13 VSS 0.0507f
C3765 FE_O_N.n14 VSS 0.05512f
C3766 FE_O_N.n15 VSS 0.05512f
C3767 FE_O_N.n16 VSS 0.0507f
C3768 FE_O_N.n17 VSS 0.15181f
C3769 FE_O_N.n18 VSS 4.97879f
C3770 FE_O_N.t3 VSS 0.52642f
C3771 FE_O_N.t4 VSS 0.18626f
C3772 FE_O_N.t5 VSS 0.18626f
C3773 FE_O_N.n19 VSS 0.32339f
C3774 FE_O_N.n20 VSS 0.16386f
C3775 FE_O_N.t6 VSS 0.52231f
C3776 FE_O_N.n21 VSS 0.24523f
C3777 FE_O_N.t0 VSS 0.18626f
C3778 FE_O_N.t1 VSS 0.18626f
C3779 FE_O_N.n22 VSS 0.32598f
C3780 FE_O_N.t2 VSS 0.52671f
C3781 FE_O_N.n23 VSS 0.282f
C3782 FE_O_N.n24 VSS 0.75156f
C3783 FE_O_N.n25 VSS 4.93723f
C3784 E_CAPTURE_CLK.n0 VSS 0.03411f
C3785 E_CAPTURE_CLK.n1 VSS 0.02336f
C3786 E_CAPTURE_CLK.n2 VSS 0.02336f
C3787 E_CAPTURE_CLK.n3 VSS 0.02336f
C3788 E_CAPTURE_CLK.n4 VSS 0.068f
C3789 E_CAPTURE_CLK.n5 VSS 0.03361f
C3790 E_CAPTURE_CLK.n6 VSS 0.03603f
C3791 E_CAPTURE_CLK.n7 VSS 0.03603f
C3792 E_CAPTURE_CLK.n8 VSS 0.03603f
C3793 E_CAPTURE_CLK.n9 VSS 0.03603f
C3794 E_CAPTURE_CLK.n10 VSS 0.03603f
C3795 E_CAPTURE_CLK.n11 VSS 0.03603f
C3796 E_CAPTURE_CLK.n12 VSS 0.01968f
C3797 E_CAPTURE_CLK.n13 VSS 0.15965f
C3798 E_CAPTURE_CLK.n14 VSS 0.03313f
C3799 E_CAPTURE_CLK.n15 VSS 0.02336f
C3800 E_CAPTURE_CLK.n16 VSS 0.03603f
C3801 E_CAPTURE_CLK.n17 VSS 0.03603f
C3802 E_CAPTURE_CLK.n18 VSS 0.03361f
C3803 E_CAPTURE_CLK.n19 VSS 0.068f
C3804 E_CAPTURE_CLK.n20 VSS 0.02336f
C3805 E_CAPTURE_CLK.n21 VSS 0.03603f
C3806 E_CAPTURE_CLK.n22 VSS 0.03603f
C3807 E_CAPTURE_CLK.n23 VSS 0.03603f
C3808 E_CAPTURE_CLK.n24 VSS 0.03603f
C3809 E_CAPTURE_CLK.n25 VSS 0.01968f
C3810 E_CAPTURE_CLK.n26 VSS 0.06564f
C3811 E_CAPTURE_CLK.n27 VSS 4.79486f
C3812 O_CAPTURE_CLK.n0 VSS 0.04244f
C3813 O_CAPTURE_CLK.n1 VSS 0.02907f
C3814 O_CAPTURE_CLK.n2 VSS 0.02907f
C3815 O_CAPTURE_CLK.n3 VSS 0.02907f
C3816 O_CAPTURE_CLK.n4 VSS 0.08462f
C3817 O_CAPTURE_CLK.n5 VSS 0.04183f
C3818 O_CAPTURE_CLK.n6 VSS 0.04483f
C3819 O_CAPTURE_CLK.n7 VSS 0.04483f
C3820 O_CAPTURE_CLK.n8 VSS 0.04483f
C3821 O_CAPTURE_CLK.n9 VSS 0.04483f
C3822 O_CAPTURE_CLK.n10 VSS 0.04483f
C3823 O_CAPTURE_CLK.n11 VSS 0.04483f
C3824 O_CAPTURE_CLK.n12 VSS 0.0245f
C3825 O_CAPTURE_CLK.n13 VSS 0.26151f
C3826 O_CAPTURE_CLK.n14 VSS 0.04123f
C3827 O_CAPTURE_CLK.n15 VSS 0.02907f
C3828 O_CAPTURE_CLK.n16 VSS 0.04483f
C3829 O_CAPTURE_CLK.n17 VSS 0.04483f
C3830 O_CAPTURE_CLK.n18 VSS 0.04183f
C3831 O_CAPTURE_CLK.n19 VSS 0.08462f
C3832 O_CAPTURE_CLK.n20 VSS 0.02907f
C3833 O_CAPTURE_CLK.n21 VSS 0.04483f
C3834 O_CAPTURE_CLK.n22 VSS 0.04483f
C3835 O_CAPTURE_CLK.n23 VSS 0.04483f
C3836 O_CAPTURE_CLK.n24 VSS 0.04483f
C3837 O_CAPTURE_CLK.n25 VSS 0.0245f
C3838 O_CAPTURE_CLK.n26 VSS 0.13772f
C3839 O_CAPTURE_CLK.n27 VSS 4.9197f
C3840 E_SENSE_CLK.n0 VSS 0.48214f
C3841 E_SENSE_CLK.n1 VSS 0.08669f
C3842 E_SENSE_CLK.n2 VSS 0.08669f
C3843 E_SENSE_CLK.n3 VSS 0.08669f
C3844 E_SENSE_CLK.n4 VSS 0.08669f
C3845 E_SENSE_CLK.n5 VSS 0.08669f
C3846 E_SENSE_CLK.n6 VSS 0.08669f
C3847 E_SENSE_CLK.n7 VSS 0.25231f
C3848 E_SENSE_CLK.n8 VSS 0.18735f
C3849 E_SENSE_CLK.n9 VSS 0.18735f
C3850 E_SENSE_CLK.n10 VSS 0.18735f
C3851 E_SENSE_CLK.n11 VSS 0.18735f
C3852 E_SENSE_CLK.n12 VSS 0.18735f
C3853 E_SENSE_CLK.n13 VSS 0.18735f
C3854 E_SENSE_CLK.n14 VSS 0.18735f
C3855 E_SENSE_CLK.n15 VSS 0.37013f
C3856 E_SENSE_CLK.n16 VSS 0.12471f
C3857 E_SENSE_CLK.n17 VSS 0.13368f
C3858 E_SENSE_CLK.n18 VSS 0.13368f
C3859 E_SENSE_CLK.n19 VSS 0.13368f
C3860 E_SENSE_CLK.n20 VSS 0.13368f
C3861 E_SENSE_CLK.n21 VSS 0.13368f
C3862 E_SENSE_CLK.n22 VSS 0.13368f
C3863 E_SENSE_CLK.n23 VSS 0.13368f
C3864 E_SENSE_CLK.n24 VSS 0.13368f
C3865 E_SENSE_CLK.n25 VSS 0.12634f
C3866 E_SENSE_CLK.n26 VSS 0.32313f
C3867 E_SENSE_CLK.n27 VSS 3.59056f
C3868 E_SENSE_CLK.n28 VSS 0.24459f
C3869 E_SENSE_CLK.n29 VSS 0.12471f
C3870 E_SENSE_CLK.n30 VSS 0.13368f
C3871 E_SENSE_CLK.n31 VSS 0.13368f
C3872 E_SENSE_CLK.n32 VSS 0.12642f
C3873 E_SENSE_CLK.n33 VSS 1.7118f
C3874 E_SENSE_CLK.n34 VSS 5.33063f
C3875 E_SENSE_CLK.n35 VSS 0.46283f
C3876 E_SENSE_CLK.n36 VSS 0.08649f
C3877 E_SENSE_CLK.n37 VSS 0.13368f
C3878 E_SENSE_CLK.n38 VSS 0.18735f
C3879 E_SENSE_CLK.n39 VSS 0.08669f
C3880 E_SENSE_CLK.n40 VSS 0.08669f
C3881 E_SENSE_CLK.n41 VSS 0.25231f
C3882 E_SENSE_CLK.n42 VSS 0.37013f
C3883 E_SENSE_CLK.n43 VSS 0.12471f
C3884 E_SENSE_CLK.n44 VSS 0.13368f
C3885 E_SENSE_CLK.n45 VSS 0.13368f
C3886 E_SENSE_CLK.n46 VSS 0.13368f
C3887 E_SENSE_CLK.n47 VSS 0.18735f
C3888 E_SENSE_CLK.n48 VSS 0.18735f
C3889 E_SENSE_CLK.n49 VSS 0.18716f
C3890 E_SENSE_CLK.n50 VSS 0.13368f
C3891 E_SENSE_CLK.n51 VSS 0.13368f
C3892 E_SENSE_CLK.n52 VSS 0.12185f
C3893 E_SENSE_CLK.n53 VSS 0.20207f
C3894 E_SENSE_CLK.n54 VSS 3.08855f
C3895 E_SENSE_CLK.n55 VSS 2.11634f
C3896 E_SENSE_CLK.n56 VSS 0.14721f
C3897 E_SENSE_CLK.n57 VSS 0.25135f
C3898 E_SENSE_CLK.n58 VSS 0.14554f
C3899 E_SENSE_CLK.n59 VSS 0.15424f
C3900 E_SENSE_CLK.n60 VSS 0.15424f
C3901 E_SENSE_CLK.n61 VSS 0.15424f
C3902 E_SENSE_CLK.n62 VSS 0.06781f
C3903 E_SENSE_CLK.n63 VSS 0.28721f
C3904 E_SENSE_CLK.n64 VSS 0.92752f
C3905 E_SENSE_CLK.n65 VSS 0.24459f
C3906 E_SENSE_CLK.n66 VSS 0.12471f
C3907 E_SENSE_CLK.n67 VSS 0.13368f
C3908 E_SENSE_CLK.n68 VSS 0.13368f
C3909 E_SENSE_CLK.n69 VSS 0.12642f
C3910 E_SENSE_CLK.n70 VSS 1.7118f
C3911 E_SENSE_CLK.n71 VSS 3.57558f
C3912 E_SENSE_CLK.n72 VSS 0.39796f
C3913 E_SENSE_CLK.n73 VSS 0.08669f
C3914 E_SENSE_CLK.n74 VSS 0.13368f
C3915 E_SENSE_CLK.n75 VSS 0.18735f
C3916 E_SENSE_CLK.n76 VSS 0.13368f
C3917 E_SENSE_CLK.n77 VSS 0.08669f
C3918 E_SENSE_CLK.n78 VSS 0.08669f
C3919 E_SENSE_CLK.n79 VSS 0.13368f
C3920 E_SENSE_CLK.n80 VSS 0.37013f
C3921 E_SENSE_CLK.n81 VSS 0.13368f
C3922 E_SENSE_CLK.n82 VSS 0.12471f
C3923 E_SENSE_CLK.n83 VSS 0.25231f
C3924 E_SENSE_CLK.n84 VSS 0.13368f
C3925 E_SENSE_CLK.n85 VSS 0.18735f
C3926 E_SENSE_CLK.n86 VSS 0.18735f
C3927 E_SENSE_CLK.n87 VSS 0.18735f
C3928 E_SENSE_CLK.n88 VSS 0.13368f
C3929 E_SENSE_CLK.n89 VSS 0.08669f
C3930 E_SENSE_CLK.n90 VSS 0.08669f
C3931 E_SENSE_CLK.n91 VSS 0.08669f
C3932 E_SENSE_CLK.n92 VSS 0.13368f
C3933 E_SENSE_CLK.n93 VSS 0.18735f
C3934 E_SENSE_CLK.n94 VSS 0.18735f
C3935 E_SENSE_CLK.n95 VSS 0.18735f
C3936 E_SENSE_CLK.n96 VSS 0.13368f
C3937 E_SENSE_CLK.n97 VSS 0.12634f
C3938 E_SENSE_CLK.n98 VSS 0.23878f
C3939 E_SENSE_CLK.n99 VSS 3.09475f
C3940 E_SENSE_CLK.n100 VSS 4.35577f
C3941 O_SENSE_CLK.n0 VSS 0.48214f
C3942 O_SENSE_CLK.n1 VSS 0.08669f
C3943 O_SENSE_CLK.n2 VSS 0.13368f
C3944 O_SENSE_CLK.n3 VSS 0.18735f
C3945 O_SENSE_CLK.n4 VSS 0.13368f
C3946 O_SENSE_CLK.n5 VSS 0.08669f
C3947 O_SENSE_CLK.n6 VSS 0.08669f
C3948 O_SENSE_CLK.n7 VSS 0.13368f
C3949 O_SENSE_CLK.n8 VSS 0.37013f
C3950 O_SENSE_CLK.n9 VSS 0.13368f
C3951 O_SENSE_CLK.n10 VSS 0.12471f
C3952 O_SENSE_CLK.n11 VSS 0.25231f
C3953 O_SENSE_CLK.n12 VSS 0.13368f
C3954 O_SENSE_CLK.n13 VSS 0.18735f
C3955 O_SENSE_CLK.n14 VSS 0.18735f
C3956 O_SENSE_CLK.n15 VSS 0.18735f
C3957 O_SENSE_CLK.n16 VSS 0.13368f
C3958 O_SENSE_CLK.n17 VSS 0.08669f
C3959 O_SENSE_CLK.n18 VSS 0.08669f
C3960 O_SENSE_CLK.n19 VSS 0.08669f
C3961 O_SENSE_CLK.n20 VSS 0.13368f
C3962 O_SENSE_CLK.n21 VSS 0.18735f
C3963 O_SENSE_CLK.n22 VSS 0.18735f
C3964 O_SENSE_CLK.n23 VSS 0.18735f
C3965 O_SENSE_CLK.n24 VSS 0.13368f
C3966 O_SENSE_CLK.n25 VSS 0.12634f
C3967 O_SENSE_CLK.n26 VSS 0.32313f
C3968 O_SENSE_CLK.n27 VSS 3.59056f
C3969 O_SENSE_CLK.n28 VSS 0.12642f
C3970 O_SENSE_CLK.n29 VSS 0.12471f
C3971 O_SENSE_CLK.n30 VSS 0.13368f
C3972 O_SENSE_CLK.n31 VSS 0.13368f
C3973 O_SENSE_CLK.n32 VSS 0.24459f
C3974 O_SENSE_CLK.n33 VSS 1.7118f
C3975 O_SENSE_CLK.n34 VSS 5.33063f
C3976 O_SENSE_CLK.n35 VSS 0.46283f
C3977 O_SENSE_CLK.n36 VSS 0.12185f
C3978 O_SENSE_CLK.n37 VSS 0.08669f
C3979 O_SENSE_CLK.n38 VSS 0.13368f
C3980 O_SENSE_CLK.n39 VSS 0.08669f
C3981 O_SENSE_CLK.n40 VSS 0.13368f
C3982 O_SENSE_CLK.n41 VSS 0.18716f
C3983 O_SENSE_CLK.n42 VSS 0.18735f
C3984 O_SENSE_CLK.n43 VSS 0.18735f
C3985 O_SENSE_CLK.n44 VSS 0.18735f
C3986 O_SENSE_CLK.n45 VSS 0.37013f
C3987 O_SENSE_CLK.n46 VSS 0.12471f
C3988 O_SENSE_CLK.n47 VSS 0.25231f
C3989 O_SENSE_CLK.n48 VSS 0.13368f
C3990 O_SENSE_CLK.n49 VSS 0.13368f
C3991 O_SENSE_CLK.n50 VSS 0.13368f
C3992 O_SENSE_CLK.n51 VSS 0.13368f
C3993 O_SENSE_CLK.n52 VSS 0.08649f
C3994 O_SENSE_CLK.n53 VSS 0.20207f
C3995 O_SENSE_CLK.n54 VSS 3.08855f
C3996 O_SENSE_CLK.n55 VSS 2.11634f
C3997 O_SENSE_CLK.n56 VSS 0.06781f
C3998 O_SENSE_CLK.n57 VSS 0.15424f
C3999 O_SENSE_CLK.n58 VSS 0.14554f
C4000 O_SENSE_CLK.n59 VSS 0.25135f
C4001 O_SENSE_CLK.n60 VSS 0.15424f
C4002 O_SENSE_CLK.n61 VSS 0.15424f
C4003 O_SENSE_CLK.n62 VSS 0.14721f
C4004 O_SENSE_CLK.n63 VSS 0.28721f
C4005 O_SENSE_CLK.n64 VSS 0.92752f
C4006 O_SENSE_CLK.n65 VSS 0.12642f
C4007 O_SENSE_CLK.n66 VSS 0.12471f
C4008 O_SENSE_CLK.n67 VSS 0.13368f
C4009 O_SENSE_CLK.n68 VSS 0.13368f
C4010 O_SENSE_CLK.n69 VSS 0.24459f
C4011 O_SENSE_CLK.n70 VSS 1.7118f
C4012 O_SENSE_CLK.n71 VSS 3.57558f
C4013 O_SENSE_CLK.n72 VSS 0.39796f
C4014 O_SENSE_CLK.n73 VSS 0.08669f
C4015 O_SENSE_CLK.n74 VSS 0.08669f
C4016 O_SENSE_CLK.n75 VSS 0.08669f
C4017 O_SENSE_CLK.n76 VSS 0.08669f
C4018 O_SENSE_CLK.n77 VSS 0.08669f
C4019 O_SENSE_CLK.n78 VSS 0.08669f
C4020 O_SENSE_CLK.n79 VSS 0.25231f
C4021 O_SENSE_CLK.n80 VSS 0.18735f
C4022 O_SENSE_CLK.n81 VSS 0.18735f
C4023 O_SENSE_CLK.n82 VSS 0.18735f
C4024 O_SENSE_CLK.n83 VSS 0.18735f
C4025 O_SENSE_CLK.n84 VSS 0.18735f
C4026 O_SENSE_CLK.n85 VSS 0.18735f
C4027 O_SENSE_CLK.n86 VSS 0.18735f
C4028 O_SENSE_CLK.n87 VSS 0.37013f
C4029 O_SENSE_CLK.n88 VSS 0.12471f
C4030 O_SENSE_CLK.n89 VSS 0.13368f
C4031 O_SENSE_CLK.n90 VSS 0.13368f
C4032 O_SENSE_CLK.n91 VSS 0.13368f
C4033 O_SENSE_CLK.n92 VSS 0.13368f
C4034 O_SENSE_CLK.n93 VSS 0.13368f
C4035 O_SENSE_CLK.n94 VSS 0.13368f
C4036 O_SENSE_CLK.n95 VSS 0.13368f
C4037 O_SENSE_CLK.n96 VSS 0.13368f
C4038 O_SENSE_CLK.n97 VSS 0.12634f
C4039 O_SENSE_CLK.n98 VSS 0.23878f
C4040 O_SENSE_CLK.n99 VSS 3.09475f
C4041 O_SENSE_CLK.n100 VSS 4.35577f
C4042 RX_RAWP.n0 VSS 0.26582f
C4043 RX_RAWP.n1 VSS 0.06998f
C4044 RX_RAWP.n2 VSS 0.04979f
C4045 RX_RAWP.n3 VSS 0.07678f
C4046 RX_RAWP.n4 VSS 0.04979f
C4047 RX_RAWP.n5 VSS 0.07678f
C4048 RX_RAWP.n6 VSS 0.10749f
C4049 RX_RAWP.n7 VSS 0.1076f
C4050 RX_RAWP.n8 VSS 0.1076f
C4051 RX_RAWP.n9 VSS 0.1076f
C4052 RX_RAWP.n10 VSS 0.21258f
C4053 RX_RAWP.n11 VSS 0.07163f
C4054 RX_RAWP.n12 VSS 0.14491f
C4055 RX_RAWP.n13 VSS 0.07678f
C4056 RX_RAWP.n14 VSS 0.07678f
C4057 RX_RAWP.n15 VSS 0.07678f
C4058 RX_RAWP.n16 VSS 0.07678f
C4059 RX_RAWP.n17 VSS 0.04967f
C4060 RX_RAWP.n18 VSS 0.11605f
C4061 RX_RAWP.n19 VSS 3.66196f
C4062 RX_RAWP.n20 VSS 0.26582f
C4063 RX_RAWP.n21 VSS 0.06998f
C4064 RX_RAWP.n22 VSS 0.04979f
C4065 RX_RAWP.n23 VSS 0.07678f
C4066 RX_RAWP.n24 VSS 0.07678f
C4067 RX_RAWP.n25 VSS 0.1076f
C4068 RX_RAWP.n26 VSS 0.04979f
C4069 RX_RAWP.n27 VSS 0.14491f
C4070 RX_RAWP.n28 VSS 0.21258f
C4071 RX_RAWP.n29 VSS 0.07163f
C4072 RX_RAWP.n30 VSS 0.07678f
C4073 RX_RAWP.n31 VSS 0.07678f
C4074 RX_RAWP.n32 VSS 0.07678f
C4075 RX_RAWP.n33 VSS 0.1076f
C4076 RX_RAWP.n34 VSS 0.1076f
C4077 RX_RAWP.n35 VSS 0.10749f
C4078 RX_RAWP.n36 VSS 0.07678f
C4079 RX_RAWP.n37 VSS 0.04967f
C4080 RX_RAWP.n38 VSS 0.11605f
C4081 RX_RAWP.n39 VSS 3.82501f
C4082 RX_RAWP.n40 VSS 11.7375f
C4083 RX_RAWP.t0 VSS 0.14769f
C4084 RX_RAWP.t1 VSS 0.41342f
C4085 RX_RAWP.t2 VSS 0.3161f
C4086 RX_RAWP.t3 VSS 0.3162f
C4087 RX_RAWP.n41 VSS 0.63962f
C4088 RX_RAWP.n42 VSS 2.10961f
C4089 RX_RAWP.n43 VSS 0.89266f
C4090 RX_RAWN.n0 VSS 0.26671f
C4091 RX_RAWN.n1 VSS 0.04984f
C4092 RX_RAWN.n2 VSS 0.07703f
C4093 RX_RAWN.n3 VSS 0.10796f
C4094 RX_RAWN.n4 VSS 0.04995f
C4095 RX_RAWN.n5 VSS 0.04995f
C4096 RX_RAWN.n6 VSS 0.1454f
C4097 RX_RAWN.n7 VSS 0.21329f
C4098 RX_RAWN.n8 VSS 0.07187f
C4099 RX_RAWN.n9 VSS 0.07703f
C4100 RX_RAWN.n10 VSS 0.07703f
C4101 RX_RAWN.n11 VSS 0.07703f
C4102 RX_RAWN.n12 VSS 0.10796f
C4103 RX_RAWN.n13 VSS 0.10796f
C4104 RX_RAWN.n14 VSS 0.10785f
C4105 RX_RAWN.n15 VSS 0.07703f
C4106 RX_RAWN.n16 VSS 0.07703f
C4107 RX_RAWN.n17 VSS 0.07022f
C4108 RX_RAWN.n18 VSS 0.11644f
C4109 RX_RAWN.n19 VSS 4.13692f
C4110 RX_RAWN.n20 VSS 0.26671f
C4111 RX_RAWN.n21 VSS 0.04984f
C4112 RX_RAWN.n22 VSS 0.07703f
C4113 RX_RAWN.n23 VSS 0.10796f
C4114 RX_RAWN.n24 VSS 0.04995f
C4115 RX_RAWN.n25 VSS 0.04995f
C4116 RX_RAWN.n26 VSS 0.1454f
C4117 RX_RAWN.n27 VSS 0.21329f
C4118 RX_RAWN.n28 VSS 0.07187f
C4119 RX_RAWN.n29 VSS 0.07703f
C4120 RX_RAWN.n30 VSS 0.07703f
C4121 RX_RAWN.n31 VSS 0.07703f
C4122 RX_RAWN.n32 VSS 0.10796f
C4123 RX_RAWN.n33 VSS 0.10796f
C4124 RX_RAWN.n34 VSS 0.10785f
C4125 RX_RAWN.n35 VSS 0.07703f
C4126 RX_RAWN.n36 VSS 0.07703f
C4127 RX_RAWN.n37 VSS 0.07022f
C4128 RX_RAWN.n38 VSS 0.11644f
C4129 RX_RAWN.n39 VSS 3.80502f
C4130 RX_RAWN.n40 VSS 10.8663f
C4131 RX_RAWN.t1 VSS 0.14192f
C4132 RX_RAWN.t2 VSS 0.42837f
C4133 RX_RAWN.t0 VSS 0.31678f
C4134 RX_RAWN.t3 VSS 0.31667f
C4135 RX_RAWN.n41 VSS 0.64176f
C4136 RX_RAWN.n42 VSS 2.25415f
C4137 RX_RAWN.n43 VSS 0.99967f
C4138 E_SENSE_BOOST.n0 VSS 0.12585f
C4139 E_SENSE_BOOST.n1 VSS 0.04212f
C4140 E_SENSE_BOOST.n2 VSS 0.07511f
C4141 E_SENSE_BOOST.n3 VSS 0.10146f
C4142 E_SENSE_BOOST.n4 VSS 0.04222f
C4143 E_SENSE_BOOST.n5 VSS 0.04222f
C4144 E_SENSE_BOOST.n6 VSS 0.04222f
C4145 E_SENSE_BOOST.n7 VSS 0.04222f
C4146 E_SENSE_BOOST.n8 VSS 0.04222f
C4147 E_SENSE_BOOST.n9 VSS 0.12288f
C4148 E_SENSE_BOOST.n10 VSS 0.10146f
C4149 E_SENSE_BOOST.n11 VSS 0.10146f
C4150 E_SENSE_BOOST.n12 VSS 0.10146f
C4151 E_SENSE_BOOST.n13 VSS 0.20071f
C4152 E_SENSE_BOOST.n14 VSS 0.07088f
C4153 E_SENSE_BOOST.n15 VSS 0.07511f
C4154 E_SENSE_BOOST.n16 VSS 0.07511f
C4155 E_SENSE_BOOST.n17 VSS 0.07511f
C4156 E_SENSE_BOOST.n18 VSS 0.07511f
C4157 E_SENSE_BOOST.n19 VSS 0.07511f
C4158 E_SENSE_BOOST.n20 VSS 0.07511f
C4159 E_SENSE_BOOST.n21 VSS 0.10146f
C4160 E_SENSE_BOOST.n22 VSS 0.10146f
C4161 E_SENSE_BOOST.n23 VSS 0.10137f
C4162 E_SENSE_BOOST.n24 VSS 0.07511f
C4163 E_SENSE_BOOST.n25 VSS 0.07511f
C4164 E_SENSE_BOOST.n26 VSS 0.04222f
C4165 E_SENSE_BOOST.n27 VSS 0.07511f
C4166 E_SENSE_BOOST.n28 VSS 0.10146f
C4167 E_SENSE_BOOST.n29 VSS 0.04222f
C4168 E_SENSE_BOOST.n30 VSS 0.04222f
C4169 E_SENSE_BOOST.n31 VSS 0.04222f
C4170 E_SENSE_BOOST.n32 VSS 0.04222f
C4171 E_SENSE_BOOST.n33 VSS 0.04222f
C4172 E_SENSE_BOOST.n34 VSS 0.04222f
C4173 E_SENSE_BOOST.n35 VSS 0.04222f
C4174 E_SENSE_BOOST.n36 VSS 0.04222f
C4175 E_SENSE_BOOST.n37 VSS 0.04222f
C4176 E_SENSE_BOOST.n38 VSS 0.12288f
C4177 E_SENSE_BOOST.n39 VSS 0.10146f
C4178 E_SENSE_BOOST.n40 VSS 0.10146f
C4179 E_SENSE_BOOST.n41 VSS 0.10146f
C4180 E_SENSE_BOOST.n42 VSS 0.10146f
C4181 E_SENSE_BOOST.n43 VSS 0.10146f
C4182 E_SENSE_BOOST.n44 VSS 0.10146f
C4183 E_SENSE_BOOST.n45 VSS 0.10146f
C4184 E_SENSE_BOOST.n46 VSS 0.10146f
C4185 E_SENSE_BOOST.n47 VSS 0.20071f
C4186 E_SENSE_BOOST.n48 VSS 0.07088f
C4187 E_SENSE_BOOST.n49 VSS 0.07511f
C4188 E_SENSE_BOOST.n50 VSS 0.07511f
C4189 E_SENSE_BOOST.n51 VSS 0.07511f
C4190 E_SENSE_BOOST.n52 VSS 0.07511f
C4191 E_SENSE_BOOST.n53 VSS 0.07511f
C4192 E_SENSE_BOOST.n54 VSS 0.07511f
C4193 E_SENSE_BOOST.n55 VSS 0.07511f
C4194 E_SENSE_BOOST.n56 VSS 0.07511f
C4195 E_SENSE_BOOST.n57 VSS 0.07511f
C4196 E_SENSE_BOOST.n58 VSS 0.07511f
C4197 E_SENSE_BOOST.n59 VSS 0.07511f
C4198 E_SENSE_BOOST.n60 VSS 0.10146f
C4199 E_SENSE_BOOST.n61 VSS 0.10146f
C4200 E_SENSE_BOOST.n62 VSS 0.10137f
C4201 E_SENSE_BOOST.n63 VSS 0.07511f
C4202 E_SENSE_BOOST.n64 VSS 0.04212f
C4203 E_SENSE_BOOST.n65 VSS 0.07607f
C4204 E_SENSE_BOOST.n66 VSS 2.29248f
C4205 O_SENSE_BOOST.n0 VSS 0.12585f
C4206 O_SENSE_BOOST.n1 VSS 0.04212f
C4207 O_SENSE_BOOST.n2 VSS 0.07511f
C4208 O_SENSE_BOOST.n3 VSS 0.10146f
C4209 O_SENSE_BOOST.n4 VSS 0.04222f
C4210 O_SENSE_BOOST.n5 VSS 0.04222f
C4211 O_SENSE_BOOST.n6 VSS 0.04222f
C4212 O_SENSE_BOOST.n7 VSS 0.04222f
C4213 O_SENSE_BOOST.n8 VSS 0.04222f
C4214 O_SENSE_BOOST.n9 VSS 0.04222f
C4215 O_SENSE_BOOST.n10 VSS 0.04222f
C4216 O_SENSE_BOOST.n11 VSS 0.04222f
C4217 O_SENSE_BOOST.n12 VSS 0.04222f
C4218 O_SENSE_BOOST.n13 VSS 0.04222f
C4219 O_SENSE_BOOST.n14 VSS 0.12288f
C4220 O_SENSE_BOOST.n15 VSS 0.10146f
C4221 O_SENSE_BOOST.n16 VSS 0.10146f
C4222 O_SENSE_BOOST.n17 VSS 0.10146f
C4223 O_SENSE_BOOST.n18 VSS 0.10146f
C4224 O_SENSE_BOOST.n19 VSS 0.10146f
C4225 O_SENSE_BOOST.n20 VSS 0.10146f
C4226 O_SENSE_BOOST.n21 VSS 0.10146f
C4227 O_SENSE_BOOST.n22 VSS 0.10146f
C4228 O_SENSE_BOOST.n23 VSS 0.20071f
C4229 O_SENSE_BOOST.n24 VSS 0.07088f
C4230 O_SENSE_BOOST.n25 VSS 0.07511f
C4231 O_SENSE_BOOST.n26 VSS 0.07511f
C4232 O_SENSE_BOOST.n27 VSS 0.07511f
C4233 O_SENSE_BOOST.n28 VSS 0.07511f
C4234 O_SENSE_BOOST.n29 VSS 0.07511f
C4235 O_SENSE_BOOST.n30 VSS 0.07511f
C4236 O_SENSE_BOOST.n31 VSS 0.07511f
C4237 O_SENSE_BOOST.n32 VSS 0.07511f
C4238 O_SENSE_BOOST.n33 VSS 0.07511f
C4239 O_SENSE_BOOST.n34 VSS 0.07511f
C4240 O_SENSE_BOOST.n35 VSS 0.07511f
C4241 O_SENSE_BOOST.n36 VSS 0.10146f
C4242 O_SENSE_BOOST.n37 VSS 0.10146f
C4243 O_SENSE_BOOST.n38 VSS 0.10137f
C4244 O_SENSE_BOOST.n39 VSS 0.07511f
C4245 O_SENSE_BOOST.n40 VSS 0.07511f
C4246 O_SENSE_BOOST.n41 VSS 0.04222f
C4247 O_SENSE_BOOST.n42 VSS 0.07511f
C4248 O_SENSE_BOOST.n43 VSS 0.10146f
C4249 O_SENSE_BOOST.n44 VSS 0.04222f
C4250 O_SENSE_BOOST.n45 VSS 0.04222f
C4251 O_SENSE_BOOST.n46 VSS 0.04222f
C4252 O_SENSE_BOOST.n47 VSS 0.04222f
C4253 O_SENSE_BOOST.n48 VSS 0.12288f
C4254 O_SENSE_BOOST.n49 VSS 0.10146f
C4255 O_SENSE_BOOST.n50 VSS 0.10146f
C4256 O_SENSE_BOOST.n51 VSS 0.10146f
C4257 O_SENSE_BOOST.n52 VSS 0.20071f
C4258 O_SENSE_BOOST.n53 VSS 0.07088f
C4259 O_SENSE_BOOST.n54 VSS 0.07511f
C4260 O_SENSE_BOOST.n55 VSS 0.07511f
C4261 O_SENSE_BOOST.n56 VSS 0.07511f
C4262 O_SENSE_BOOST.n57 VSS 0.07511f
C4263 O_SENSE_BOOST.n58 VSS 0.07511f
C4264 O_SENSE_BOOST.n59 VSS 0.07511f
C4265 O_SENSE_BOOST.n60 VSS 0.10146f
C4266 O_SENSE_BOOST.n61 VSS 0.10146f
C4267 O_SENSE_BOOST.n62 VSS 0.10137f
C4268 O_SENSE_BOOST.n63 VSS 0.07511f
C4269 O_SENSE_BOOST.n64 VSS 0.04212f
C4270 O_SENSE_BOOST.n65 VSS 0.07607f
C4271 O_SENSE_BOOST.n66 VSS 2.29248f
C4272 RX_BW_EN_N.n0 VSS 2.42173f
C4273 RX_BW_EN_N.n1 VSS 2.35569f
C4274 VTHP.n0 VSS 0.29419f
C4275 VTHN.n0 VSS 0.29419f
C4276 RX_BIAS.n0 VSS 0.02779f
C4277 RX_BIAS.n1 VSS 0.02951f
C4278 RX_BIAS.n2 VSS 0.02951f
C4279 RX_BIAS.n3 VSS 0.02951f
C4280 RX_BIAS.n4 VSS 0.02779f
C4281 RX_BIAS.n5 VSS 0.11903f
C4282 RX_BIAS.n6 VSS 0.01107f
C4283 RX_BIAS.n7 VSS 0.01376f
C4284 RX_BIAS.n8 VSS 0.01376f
C4285 RX_BIAS.n9 VSS 0.01107f
C4286 RX_BIAS.n10 VSS 0.27482f
C4287 RX_BIAS.n11 VSS 0.02779f
C4288 RX_BIAS.n12 VSS 0.02951f
C4289 RX_BIAS.n13 VSS 0.02951f
C4290 RX_BIAS.n14 VSS 0.02951f
C4291 RX_BIAS.n15 VSS 0.02779f
C4292 RX_BIAS.n16 VSS 0.10781f
C4293 RX_BIAS.n17 VSS 0.72566f
C4294 RX_BIAS.n18 VSS 0.71306f
C4295 RXP.t5 VSS 0.17679f
C4296 RXP.n0 VSS 0.53688f
C4297 RXP.n1 VSS 2.22357f
C4298 RXP.t4 VSS 0.03579f
C4299 RXP.t3 VSS 0.03579f
C4300 RXP.t1 VSS 0.03579f
C4301 RXP.t6 VSS 0.03579f
C4302 RXP.t7 VSS 0.03579f
C4303 RXP.t0 VSS 0.03521f
C4304 RXP.t2 VSS 0.05232f
C4305 RXP.n2 VSS 0.77427f
C4306 RXP.n3 VSS 0.46432f
C4307 RXP.n4 VSS 0.46432f
C4308 RXP.n5 VSS 0.46432f
C4309 RXP.n6 VSS 0.46432f
C4310 RXP.n7 VSS 0.42573f
C4311 RXN.t7 VSS 0.07015f
C4312 RXN.n0 VSS 0.21303f
C4313 RXN.n1 VSS 0.88229f
C4314 RXN.t6 VSS 0.0142f
C4315 RXN.t1 VSS 0.0142f
C4316 RXN.t0 VSS 0.0142f
C4317 RXN.t3 VSS 0.0142f
C4318 RXN.t4 VSS 0.0142f
C4319 RXN.t5 VSS 0.01397f
C4320 RXN.t2 VSS 0.02076f
C4321 RXN.n2 VSS 0.30723f
C4322 RXN.n3 VSS 0.18424f
C4323 RXN.n4 VSS 0.18424f
C4324 RXN.n5 VSS 0.18424f
C4325 RXN.n6 VSS 0.18424f
C4326 RXN.n7 VSS 0.16893f
C4327 TERM_EN6_N.n0 VSS 0.40332f
C4328 TERM_EN6_N.n1 VSS 1.74029f
C4329 TERM_EN6_N.n2 VSS 0.71327f
C4330 TERM_EN5_N.n0 VSS 0.41634f
C4331 TERM_EN5_N.n1 VSS 1.79643f
C4332 TERM_EN5_N.n2 VSS 0.73628f
C4333 TERM_EN4_N.n0 VSS 0.41634f
C4334 TERM_EN4_N.n1 VSS 1.79643f
C4335 TERM_EN4_N.n2 VSS 0.73628f
C4336 TERM_EN3_N.n0 VSS 0.41634f
C4337 TERM_EN3_N.n1 VSS 1.79643f
C4338 TERM_EN3_N.n2 VSS 0.73628f
C4339 TERM_EN2_N.n0 VSS 0.41634f
C4340 TERM_EN2_N.n1 VSS 1.79643f
C4341 TERM_EN2_N.n2 VSS 0.73628f
C4342 TERM_EN1_N.n0 VSS 0.41296f
C4343 TERM_EN1_N.n1 VSS 1.78188f
C4344 TERM_EN1_N.n2 VSS 0.73031f
C4345 TERM_EN0_N.n0 VSS 0.38663f
C4346 TERM_EN0_N.n1 VSS 1.66825f
C4347 TERM_EN0_N.n2 VSS 0.68374f
.ends
