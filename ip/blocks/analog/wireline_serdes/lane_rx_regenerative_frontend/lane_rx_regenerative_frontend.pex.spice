* PEX produced using /foss/tools/sak/sak-pex.sh with m=3 and s=1 (extresist threshold=0 mOhm, minres=1 mOhm, mindelay=0 ps)
* NGSPICE file created from lane_rx_regenerative_frontend_pex.ext - technology: gf180mcuD

.subckt lane_rx_regenerative_frontend_pex RXP RXN TERM_EN0_N TERM_EN1_N TERM_EN2_N
+ TERM_EN3_N TERM_EN4_N TERM_EN5_N TERM_EN6_N VTHP VTHN RX_BIAS RX_BW_EN_N E_SENSE_CLK
+ E_REGEN_CLK E_REGEN_CLKB E_CAPTURE_CLK E_CAPTURE_CLKB E_SENSE_BOOST O_SENSE_CLK
+ O_REGEN_CLK O_REGEN_CLKB O_CAPTURE_CLK O_CAPTURE_CLKB O_SENSE_BOOST VDD VSS RX_RAWP
+ RX_RAWN FE_E_P FE_E_N FE_O_P FE_O_N
X0 VSS.t111 RX_BIAS.t4 a_2148_n500.t1 VSS.t99 nfet_03v3 ad=2.6p pd=10.52u as=4.4p ps=20.88u w=10u l=0.28u
X1 a_n10800_n17972.t0 TERM_EN3_N.t2 VSS.t353 VSS.t2 nfet_03v3 ad=0.44p pd=2.88u as=0.44p ps=2.88u w=1u l=0.28u
X2 FE_E_N.t5 XFE_E.H.t17 VSS.t370 VSS.t369 nfet_03v3 ad=3.52p pd=16.88u as=2.08p ps=8.52u w=8u l=0.28u
X3 XFE_O.NIP.t19 RX_RAWP.t8 XFE_O.NTAIL.t16 VSS.t246 nfet_03v3 ad=2.08p pd=8.52u as=2.08p ps=8.52u w=8u l=0.28u
X4 VDD.t199 XFE_O.HB.t28 XFE_O.H.t13 VDD.t198 pfet_03v3 ad=2.08p pd=8.52u as=3.52p ps=16.88u w=8u l=0.28u
X5 XFE_O.XP.t1 XFE_O.XN.t36 XFE_O.NIP.t1 VSS.t8 nfet_03v3 ad=2.08p pd=8.52u as=2.08p ps=8.52u w=8u l=0.28u
X6 VSS.t12 XFE_E.XP.t45 XFE_E.DP.t0 VSS.t11 nfet_03v3 ad=2.08p pd=8.52u as=3.52p ps=16.88u w=8u l=0.28u
X7 a_n7157_n21700.t2 a_n10800_n21572.t3 a_n6400_n21652.t3 VSS.t182 nfet_03v3 ad=4.4p pd=20.88u as=2.6p ps=10.52u w=10u l=0.28u
X8 VSS.t148 E_SENSE_BOOST.t11 XFE_E.NTAIL.t20 VSS.t147 nfet_03v3 ad=2.6p pd=10.52u as=2.6p ps=10.52u w=10u l=0.28u
X9 VDD.t227 E_SENSE_CLK.t28 XFE_E.NIN.t22 VDD.t226 pfet_03v3 ad=2.08p pd=8.52u as=2.08p ps=8.52u w=8u l=0.28u
X10 a_2148_n500.t6 a_n6572_3500.t7 RX_RAWP.t1 VSS.t4 nfet_03v3 ad=1.3p pd=5.52u as=2.2p ps=10.88u w=5u l=0.28u
X11 XFE_E.XN.t7 XFE_E.XP.t36 XFE_E.NIN.t7 VSS.t181 nfet_03v3 ad=2.08p pd=8.52u as=2.08p ps=8.52u w=8u l=0.28u
X12 XFE_O.NTAIL.t19 RX_RAWP.t5 XFE_O.NIP.t22 VSS.t249 nfet_03v3 ad=2.08p pd=8.52u as=2.08p ps=8.52u w=8u l=0.28u
X13 XFE_E.XP.t15 E_SENSE_CLK.t13 VDD.t249 VDD.t248 pfet_03v3 ad=2.08p pd=8.52u as=2.08p ps=8.52u w=8u l=0.28u
X14 a_n5052_2600.t7 VTHN.t1 a_n3600_5641.t3 VSS.t213 nfet_03v3 ad=0.52p pd=2.52u as=0.88p ps=4.88u w=2u l=0.28u
X15 XFE_E.NIN.t15 RX_RAWP.t16 XFE_E.NTAIL.t32 VSS.t238 nfet_03v3 ad=2.08p pd=8.52u as=2.08p ps=8.52u w=8u l=0.28u
X16 VDD.t195 XFE_O.XP.t53 XFE_O.HB.t14 VDD.t194 pfet_03v3 ad=2.08p pd=8.52u as=3.52p ps=16.88u w=8u l=0.28u
X17 VSS.t98 RX_BIAS.t13 a_n5052_2600.t0 VSS.t97 nfet_03v3 ad=0.52p pd=2.52u as=0.88p ps=4.88u w=2u l=0.28u
X18 XFE_E.NTAIL.t17 E_SENSE_BOOST.t14 VSS.t142 VSS.t141 nfet_03v3 ad=2.6p pd=10.52u as=2.6p ps=10.52u w=10u l=0.28u
X19 VDD.t107 O_SENSE_CLK.t36 XFE_O.XP.t26 VDD.t106 pfet_03v3 ad=2.08p pd=8.52u as=2.08p ps=8.52u w=8u l=0.28u
X20 XFE_O.NIN.t17 XFE_O.XP.t41 XFE_O.XN.t20 VSS.t217 nfet_03v3 ad=2.08p pd=8.52u as=2.08p ps=8.52u w=8u l=0.28u
X21 a_n6400_n18052.t1 a_n10800_n17972.t2 a_n7300_n18100.t2 VSS.t266 nfet_03v3 ad=2.6p pd=10.52u as=4.4p ps=20.88u w=10u l=0.28u
X22 VSS.t350 O_SENSE_BOOST.t1 XFE_O.NTAIL.t43 VSS.t349 nfet_03v3 ad=2.6p pd=10.52u as=2.6p ps=10.52u w=10u l=0.28u
X23 XFE_E.NIN.t2 XFE_E.XP.t39 XFE_E.XN.t2 VSS.t51 nfet_03v3 ad=2.08p pd=8.52u as=2.08p ps=8.52u w=8u l=0.28u
X24 XFE_E.XN.t26 E_SENSE_CLK.t33 VDD.t219 VDD.t218 pfet_03v3 ad=2.08p pd=8.52u as=2.08p ps=8.52u w=8u l=0.28u
X25 VDD.t66 XFE_O.H.t23 XFE_O.HB.t4 VDD.t65 pfet_03v3 ad=2.08p pd=8.52u as=2.08p ps=8.52u w=8u l=0.28u
X26 XFE_O.XN.t16 O_SENSE_CLK.t20 XFE_O.XP.t21 VDD.t132 pfet_03v3 ad=2.08p pd=8.52u as=2.08p ps=8.52u w=8u l=0.28u
X27 XFE_O.XP.t6 XFE_O.XN.t42 XFE_O.NIP.t5 VSS.t47 nfet_03v3 ad=2.08p pd=8.52u as=2.08p ps=8.52u w=8u l=0.28u
X28 VDD.t239 E_SENSE_CLK.t18 XFE_E.NIP.t20 VDD.t238 pfet_03v3 ad=2.08p pd=8.52u as=3.52p ps=16.88u w=8u l=0.28u
X29 VSS.t160 E_SENSE_BOOST.t5 XFE_E.NTAIL.t26 VSS.t159 nfet_03v3 ad=2.6p pd=10.52u as=2.6p ps=10.52u w=10u l=0.28u
X30 XFE_O.H.t9 XFE_O.XN.t52 VDD.t95 VDD.t94 pfet_03v3 ad=3.52p pd=16.88u as=2.08p ps=8.52u w=8u l=0.28u
X31 XFE_O.HB.t15 XFE_O.XP.t50 VDD.t289 VDD.t288 pfet_03v3 ad=3.52p pd=16.88u as=2.08p ps=8.52u w=8u l=0.28u
X32 a_n6400_n12652.t4 RXN.t5 VSS.t267 ppolyf_u r_width=1u r_length=1u
X33 FE_E_N.t0 XFE_E.H.t22 VDD.t31 VDD.t30 pfet_03v3 ad=3.52p pd=16.88u as=2.08p ps=8.52u w=8u l=0.28u
X34 VDD.t77 XFE_E.XP.t51 XFE_E.XN.t9 VDD.t76 pfet_03v3 ad=2.08p pd=8.52u as=3.52p ps=16.88u w=8u l=0.28u
X35 RXP.t2 a_n7157_n23500.t1 VSS.t77 ppolyf_u r_width=1u r_length=2.43u
X36 FE_O_N.t2 XFE_O.HB.t19 VSS.t292 VSS.t291 nfet_03v3 ad=2.08p pd=8.52u as=2.08p ps=8.52u w=8u l=0.28u
X37 a_n5052_2600.t1 RX_BIAS.t12 VSS.t104 VSS.t97 nfet_03v3 ad=0.52p pd=2.52u as=0.52p ps=2.52u w=2u l=0.28u
X38 XFE_O.XP.t29 O_SENSE_CLK.t33 VDD.t113 VDD.t112 pfet_03v3 ad=2.08p pd=8.52u as=2.08p ps=8.52u w=8u l=0.28u
X39 XFE_O.HB.t12 XFE_O.DN.t6 VSS.t361 VSS.t360 nfet_03v3 ad=3.52p pd=16.88u as=2.08p ps=8.52u w=8u l=0.28u
X40 XFE_E.HB.t8 XFE_E.DN.t8 VSS.t357 VSS.t356 nfet_03v3 ad=2.08p pd=8.52u as=2.08p ps=8.52u w=8u l=0.28u
X41 VDD.t211 E_SENSE_CLK.t36 XFE_E.XN.t23 VDD.t210 pfet_03v3 ad=2.08p pd=8.52u as=2.08p ps=8.52u w=8u l=0.28u
X42 XFE_O.NIP.t2 XFE_O.XN.t39 XFE_O.XP.t3 VSS.t19 nfet_03v3 ad=2.08p pd=8.52u as=2.08p ps=8.52u w=8u l=0.28u
X43 XFE_E.NIP.t5 XFE_E.XN.t41 XFE_E.XP.t2 VSS.t68 nfet_03v3 ad=2.08p pd=8.52u as=2.08p ps=8.52u w=8u l=0.28u
X44 XFE_O.NTAIL.t24 O_SENSE_BOOST.t20 VSS.t314 VSS.t313 nfet_03v3 ad=2.6p pd=10.52u as=2.6p ps=10.52u w=10u l=0.28u
X45 XFE_E.NTAIL.t23 E_SENSE_BOOST.t8 VSS.t154 VSS.t153 nfet_03v3 ad=2.6p pd=10.52u as=2.6p ps=10.52u w=10u l=0.28u
X46 XFE_E.NIP.t7 RX_RAWN.t18 XFE_E.NTAIL.t4 VSS.t80 nfet_03v3 ad=2.08p pd=8.52u as=2.08p ps=8.52u w=8u l=0.28u
X47 VDD.t56 XFE_O.XN.t47 XFE_O.DN.t4 VDD.t55 pfet_03v3 ad=2.08p pd=8.52u as=2.08p ps=8.52u w=8u l=0.28u
X48 VSS.t339 O_SENSE_BOOST.t7 XFE_O.NTAIL.t37 VSS.t5 nfet_03v3 ad=2.6p pd=10.52u as=2.6p ps=10.52u w=10u l=0.28u
X49 a_n10800_n23372.t0 TERM_EN0_N.t2 VSS.t368 VSS.t2 nfet_03v3 ad=0.44p pd=2.88u as=0.44p ps=2.88u w=1u l=0.28u
X50 VSS.t300 XFE_E.DN.t11 XFE_E.HB.t5 VSS.t299 nfet_03v3 ad=2.08p pd=8.52u as=2.08p ps=8.52u w=8u l=0.28u
X51 XFE_E.DP.t1 XFE_E.XP.t46 VDD.t17 VDD.t16 pfet_03v3 ad=3.52p pd=16.88u as=2.08p ps=8.52u w=8u l=0.28u
X52 XFE_E.NTAIL.t38 RX_RAWP.t13 XFE_E.NIN.t18 VSS.t241 nfet_03v3 ad=2.08p pd=8.52u as=2.08p ps=8.52u w=8u l=0.28u
X53 XFE_E.XN.t18 E_SENSE_CLK.t26 XFE_E.XP.t24 VDD.t230 pfet_03v3 ad=2.08p pd=8.52u as=3.52p ps=16.88u w=8u l=0.28u
X54 a_n7300_n14500.t2 TERM_EN5_N.t1 a_n6400_n14452.t3 VDD.t182 pfet_03v3 ad=4.4p pd=20.88u as=2.6p ps=10.52u w=10u l=0.28u
X55 XFE_E.NTAIL.t9 E_SENSE_BOOST.t22 VSS.t128 VSS.t127 nfet_03v3 ad=2.6p pd=10.52u as=2.6p ps=10.52u w=10u l=0.28u
X56 XFE_E.HB.t14 XFE_E.H.t27 VDD.t168 VDD.t167 pfet_03v3 ad=2.08p pd=8.52u as=2.08p ps=8.52u w=8u l=0.28u
X57 VDD.t281 XFE_O.HB.t26 XFE_O.H.t15 VDD.t280 pfet_03v3 ad=2.08p pd=8.52u as=2.08p ps=8.52u w=8u l=0.28u
X58 XFE_O.HB.t6 XFE_O.DN.t12 VSS.t270 VSS.t269 nfet_03v3 ad=2.08p pd=8.52u as=2.08p ps=8.52u w=8u l=0.28u
X59 XFE_O.NTAIL.t40 O_SENSE_BOOST.t4 VSS.t344 VSS.t343 nfet_03v3 ad=2.6p pd=10.52u as=2.6p ps=10.52u w=10u l=0.28u
X60 XFE_E.H.t16 XFE_E.DP.t6 VSS.t120 VSS.t119 nfet_03v3 ad=3.52p pd=16.88u as=2.08p ps=8.52u w=8u l=0.28u
X61 XFE_O.XP.t14 O_SENSE_CLK.t23 XFE_O.XN.t13 VDD.t129 pfet_03v3 ad=2.08p pd=8.52u as=2.08p ps=8.52u w=8u l=0.28u
X62 XFE_E.NIP.t23 E_SENSE_CLK.t15 VDD.t243 VDD.t242 pfet_03v3 ad=3.52p pd=16.88u as=2.08p ps=8.52u w=8u l=0.28u
X63 VDD.t269 XFE_E.XP.t49 XFE_E.DP.t5 VDD.t268 pfet_03v3 ad=2.08p pd=8.52u as=3.52p ps=16.88u w=8u l=0.28u
X64 XFE_O.XN.t7 O_SENSE_CLK.t7 VDD.t155 VDD.t154 pfet_03v3 ad=2.08p pd=8.52u as=2.08p ps=8.52u w=8u l=0.28u
X65 XFE_E.NIP.t13 RX_RAWN.t12 XFE_E.NTAIL.t7 VSS.t86 nfet_03v3 ad=3.52p pd=16.88u as=2.08p ps=8.52u w=8u l=0.28u
X66 a_n5052_n1000.t3 RX_BIAS.t8 VSS.t102 VSS.t101 nfet_03v3 ad=2.6p pd=10.52u as=2.6p ps=10.52u w=10u l=0.28u
X67 a_n10800_n12572.t1 TERM_EN6_N.t3 VDD.t1 VDD.t0 pfet_03v3 ad=0.88p pd=4.88u as=0.88p ps=4.88u w=2u l=0.28u
X68 XFE_E.NTAIL.t40 E_SENSE_CLK.t4 VSS.t276 VSS.t275 nfet_03v3 ad=2.6p pd=10.52u as=4.4p ps=20.88u w=10u l=0.28u
X69 VDD.t72 XFE_O.XN.t55 XFE_O.H.t0 VDD.t71 pfet_03v3 ad=2.08p pd=8.52u as=3.52p ps=16.88u w=8u l=0.28u
X70 VDD.t223 E_SENSE_CLK.t30 XFE_E.NIN.t20 VDD.t222 pfet_03v3 ad=2.08p pd=8.52u as=3.52p ps=16.88u w=8u l=0.28u
X71 FE_O_N.t5 XFE_O.HB.t23 VDD.t275 VDD.t274 pfet_03v3 ad=2.08p pd=8.52u as=2.08p ps=8.52u w=8u l=0.28u
X72 XFE_E.H.t4 XFE_E.HB.t22 VDD.t87 VDD.t86 pfet_03v3 ad=3.52p pd=16.88u as=2.08p ps=8.52u w=8u l=0.28u
X73 FE_O_P.t0 XFE_O.H.t18 VSS.t23 VSS.t22 nfet_03v3 ad=3.52p pd=16.88u as=2.08p ps=8.52u w=8u l=0.28u
X74 a_n7300_n18100.t3 TERM_EN3_N.t1 a_n6400_n18052.t4 VDD.t298 pfet_03v3 ad=4.4p pd=20.88u as=2.6p ps=10.52u w=10u l=0.28u
X75 RX_RAWP.t0 RX_BW_EN_N.t1 a_484_3500.t0 VDD.t51 pfet_03v3 ad=2.2p pd=10.88u as=2.2p ps=10.88u w=5u l=0.28u
X76 a_n6400_n16252.t0 RXN.t3 VSS.t171 ppolyf_u r_width=1u r_length=1u
X77 VSS.t76 XFE_O.DN.t9 XFE_O.HB.t9 VSS.t75 nfet_03v3 ad=2.08p pd=8.52u as=2.08p ps=8.52u w=8u l=0.28u
X78 XFE_O.NTAIL.t0 RX_RAWN.t11 XFE_O.NIN.t8 VSS.t87 nfet_03v3 ad=2.08p pd=8.52u as=3.52p ps=16.88u w=8u l=0.28u
X79 VSS.t219 O_SENSE_CLK.t4 XFE_O.NTAIL.t8 VSS.t218 nfet_03v3 ad=2.6p pd=10.52u as=4.4p ps=20.88u w=10u l=0.28u
X80 XFE_E.DN.t0 XFE_E.XN.t48 VDD.t11 VDD.t10 pfet_03v3 ad=2.08p pd=8.52u as=2.08p ps=8.52u w=8u l=0.28u
X81 a_n6400_n23452.t2 a_n10800_n23372.t2 a_n7157_n23500.t2 VSS.t297 nfet_03v3 ad=2.6p pd=10.52u as=4.4p ps=20.88u w=10u l=0.28u
X82 VSS.t308 O_SENSE_BOOST.t23 XFE_O.NTAIL.t21 VSS.t307 nfet_03v3 ad=2.6p pd=10.52u as=4.4p ps=20.88u w=10u l=0.28u
X83 XFE_E.NTAIL.t15 E_SENSE_BOOST.t16 VSS.t138 VSS.t9 nfet_03v3 ad=2.6p pd=10.52u as=2.6p ps=10.52u w=10u l=0.28u
X84 XFE_E.XP.t23 E_SENSE_CLK.t5 VDD.t265 VDD.t264 pfet_03v3 ad=3.52p pd=16.88u as=2.08p ps=8.52u w=8u l=0.28u
X85 XFE_E.NTAIL.t0 RX_RAWN.t15 XFE_E.NIP.t10 VSS.t83 nfet_03v3 ad=2.08p pd=8.52u as=2.08p ps=8.52u w=8u l=0.28u
X86 XFE_E.H.t3 XFE_E.HB.t17 VSS.t192 VSS.t191 nfet_03v3 ad=3.52p pd=16.88u as=3.52p ps=16.88u w=8u l=0.28u
X87 RX_RAWN.t1 a_n3600_5641.t6 a_2148_n500.t0 VSS.t4 nfet_03v3 ad=2.2p pd=10.88u as=1.3p ps=5.52u w=5u l=0.28u
X88 VDD.t115 O_SENSE_CLK.t32 XFE_O.XP.t30 VDD.t114 pfet_03v3 ad=2.08p pd=8.52u as=2.08p ps=8.52u w=8u l=0.28u
X89 a_n1900_5958.t0 RX_BW_EN_N.t2 a_n3600_5641.t2 VDD.t50 pfet_03v3 ad=2.2p pd=10.88u as=2.2p ps=10.88u w=5u l=0.28u
X90 a_n6400_n12652.t1 TERM_EN6_N.t0 a_n7300_n12700.t1 VDD.t3 pfet_03v3 ad=2.6p pd=10.52u as=4.4p ps=20.88u w=10u l=0.28u
X91 VDD.t75 XFE_E.HB.t25 XFE_E.H.t2 VDD.t74 pfet_03v3 ad=2.08p pd=8.52u as=3.52p ps=16.88u w=8u l=0.28u
X92 XFE_O.NTAIL.t11 O_SENSE_CLK.t1 VSS.t225 VSS.t224 nfet_03v3 ad=2.6p pd=10.52u as=2.6p ps=10.52u w=10u l=0.28u
X93 RXP.t3 a_n7300_n12700.t2 VSS.t77 ppolyf_u r_width=1u r_length=1u
X94 VSS.t134 E_SENSE_BOOST.t19 XFE_E.NTAIL.t12 VSS.t133 nfet_03v3 ad=2.6p pd=10.52u as=2.6p ps=10.52u w=10u l=0.28u
X95 a_n6400_n19852.t0 RXN.t0 VSS.t49 ppolyf_u r_width=1u r_length=1u
X96 XFE_O.XN.t25 XFE_O.XP.t36 XFE_O.NIN.t6 VSS.t53 nfet_03v3 ad=2.08p pd=8.52u as=2.08p ps=8.52u w=8u l=0.28u
X97 VDD.t85 XFE_O.H.t28 FE_O_P.t6 VDD.t84 pfet_03v3 ad=2.08p pd=8.52u as=3.52p ps=16.88u w=8u l=0.28u
X98 VDD.t203 E_SENSE_CLK.t38 XFE_E.XN.t21 VDD.t202 pfet_03v3 ad=2.08p pd=8.52u as=2.08p ps=8.52u w=8u l=0.28u
X99 a_n6572_3500.t1 RX_BW_EN_N.t3 a_n6716_3500.t0 VDD.t49 pfet_03v3 ad=2.2p pd=10.88u as=2.2p ps=10.88u w=5u l=0.28u
X100 XFE_E.DP.t4 XFE_E.XP.t44 VSS.t204 VSS.t203 nfet_03v3 ad=3.52p pd=16.88u as=2.08p ps=8.52u w=8u l=0.28u
X101 XFE_E.NTAIL.t21 E_SENSE_BOOST.t10 VSS.t150 VSS.t149 nfet_03v3 ad=2.6p pd=10.52u as=2.6p ps=10.52u w=10u l=0.28u
X102 VSS.t41 XFE_E.DP.t7 XFE_E.H.t15 VSS.t40 nfet_03v3 ad=2.08p pd=8.52u as=2.08p ps=8.52u w=8u l=0.28u
X103 VDD.t151 O_SENSE_CLK.t10 XFE_O.XN.t4 VDD.t150 pfet_03v3 ad=2.08p pd=8.52u as=2.08p ps=8.52u w=8u l=0.28u
X104 VSS.t113 RX_BIAS.t2 a_2148_n500.t3 VSS.t99 nfet_03v3 ad=2.6p pd=10.52u as=2.6p ps=10.52u w=10u l=0.28u
X105 VDD.t162 XFE_E.HB.t27 FE_E_P.t5 VDD.t161 pfet_03v3 ad=2.08p pd=8.52u as=2.08p ps=8.52u w=8u l=0.28u
X106 XFE_E.NIN.t23 E_SENSE_CLK.t27 VDD.t229 VDD.t228 pfet_03v3 ad=3.52p pd=16.88u as=2.08p ps=8.52u w=8u l=0.28u
X107 XFE_E.NIP.t3 XFE_E.XN.t33 XFE_E.XP.t10 VSS.t39 nfet_03v3 ad=2.08p pd=8.52u as=2.08p ps=8.52u w=8u l=0.28u
X108 a_n10800_n16172.t1 TERM_EN4_N.t3 VDD.t177 VDD.t176 pfet_03v3 ad=0.88p pd=4.88u as=0.88p ps=4.88u w=2u l=0.28u
X109 VSS.t73 XFE_O.H.t21 FE_O_P.t3 VSS.t72 nfet_03v3 ad=2.08p pd=8.52u as=3.52p ps=16.88u w=8u l=0.28u
X110 XFE_O.XP.t10 XFE_O.XN.t34 XFE_O.NIP.t9 VSS.t61 nfet_03v3 ad=2.08p pd=8.52u as=2.08p ps=8.52u w=8u l=0.28u
X111 VSS.t326 O_SENSE_BOOST.t15 XFE_O.NTAIL.t29 VSS.t325 nfet_03v3 ad=2.6p pd=10.52u as=2.6p ps=10.52u w=10u l=0.28u
X112 VSS.t144 E_SENSE_BOOST.t13 XFE_E.NTAIL.t18 VSS.t143 nfet_03v3 ad=2.6p pd=10.52u as=2.6p ps=10.52u w=10u l=0.28u
X113 XFE_E.H.t12 XFE_E.DP.t10 VSS.t43 VSS.t42 nfet_03v3 ad=2.08p pd=8.52u as=2.08p ps=8.52u w=8u l=0.28u
X114 XFE_O.XN.t19 XFE_O.XP.t42 XFE_O.NIN.t22 VSS.t305 nfet_03v3 ad=2.08p pd=8.52u as=2.08p ps=8.52u w=8u l=0.28u
X115 VSS.t18 XFE_E.HB.t19 FE_E_P.t2 VSS.t17 nfet_03v3 ad=2.08p pd=8.52u as=2.08p ps=8.52u w=8u l=0.28u
X116 VDD.t221 E_SENSE_CLK.t32 XFE_E.XN.t27 VDD.t220 pfet_03v3 ad=2.08p pd=8.52u as=2.08p ps=8.52u w=8u l=0.28u
X117 XFE_O.NTAIL.t42 O_SENSE_BOOST.t2 VSS.t348 VSS.t347 nfet_03v3 ad=2.6p pd=10.52u as=2.6p ps=10.52u w=10u l=0.28u
X118 XFE_O.HB.t0 XFE_O.H.t24 VDD.t45 VDD.t44 pfet_03v3 ad=2.08p pd=8.52u as=2.08p ps=8.52u w=8u l=0.28u
X119 XFE_E.NIN.t13 RX_RAWP.t18 XFE_E.NTAIL.t36 VSS.t236 nfet_03v3 ad=2.08p pd=8.52u as=2.08p ps=8.52u w=8u l=0.28u
X120 VSS.t185 XFE_O.DP.t13 XFE_O.H.t1 VSS.t184 nfet_03v3 ad=2.08p pd=8.52u as=3.52p ps=16.88u w=8u l=0.28u
X121 VDD.t291 XFE_O.XP.t51 XFE_O.HB.t16 VDD.t290 pfet_03v3 ad=2.08p pd=8.52u as=2.08p ps=8.52u w=8u l=0.28u
X122 a_n6400_n16252.t2 TERM_EN4_N.t0 a_n7300_n16300.t3 VDD.t179 pfet_03v3 ad=2.6p pd=10.52u as=4.4p ps=20.88u w=10u l=0.28u
X123 VDD.t164 XFE_O.XN.t53 XFE_O.H.t10 VDD.t163 pfet_03v3 ad=2.08p pd=8.52u as=2.08p ps=8.52u w=8u l=0.28u
X124 a_n10800_n19772.t1 TERM_EN2_N.t3 VDD.t68 VDD.t67 pfet_03v3 ad=0.88p pd=4.88u as=0.88p ps=4.88u w=2u l=0.28u
X125 XFE_E.XN.t31 XFE_E.XP.t50 VDD.t271 VDD.t270 pfet_03v3 ad=3.52p pd=16.88u as=2.08p ps=8.52u w=8u l=0.28u
X126 XFE_E.XP.t31 E_SENSE_CLK.t19 XFE_E.XN.t13 VDD.t237 pfet_03v3 ad=3.52p pd=16.88u as=2.08p ps=8.52u w=8u l=0.28u
X127 XFE_O.NIN.t1 XFE_O.XP.t39 XFE_O.XN.t22 VSS.t1 nfet_03v3 ad=2.08p pd=8.52u as=2.08p ps=8.52u w=8u l=0.28u
X128 VSS.t272 XFE_O.DN.t7 XFE_O.HB.t11 VSS.t271 nfet_03v3 ad=2.08p pd=8.52u as=2.08p ps=8.52u w=8u l=0.28u
X129 XFE_E.XN.t24 E_SENSE_CLK.t35 VDD.t215 VDD.t214 pfet_03v3 ad=2.08p pd=8.52u as=2.08p ps=8.52u w=8u l=0.28u
X130 XFE_O.NTAIL.t2 RX_RAWN.t9 XFE_O.NIN.t10 VSS.t89 nfet_03v3 ad=2.08p pd=8.52u as=2.08p ps=8.52u w=8u l=0.28u
X131 XFE_E.NIN.t4 XFE_E.XP.t41 XFE_E.XN.t4 VSS.t62 nfet_03v3 ad=2.08p pd=8.52u as=2.08p ps=8.52u w=8u l=0.28u
X132 RXP.t1 a_n7300_n16300.t0 VSS.t77 ppolyf_u r_width=1u r_length=1u
X133 XFE_O.XP.t4 XFE_O.XN.t40 XFE_O.NIP.t3 VSS.t20 nfet_03v3 ad=2.08p pd=8.52u as=2.08p ps=8.52u w=8u l=0.28u
X134 XFE_O.DP.t2 XFE_O.XP.t46 VDD.t293 VDD.t292 pfet_03v3 ad=3.52p pd=16.88u as=2.08p ps=8.52u w=8u l=0.28u
X135 VSS.t312 O_SENSE_BOOST.t21 XFE_O.NTAIL.t23 VSS.t311 nfet_03v3 ad=2.6p pd=10.52u as=2.6p ps=10.52u w=10u l=0.28u
X136 XFE_E.NTAIL.t5 RX_RAWN.t17 XFE_E.NIP.t8 VSS.t81 nfet_03v3 ad=2.08p pd=8.52u as=2.08p ps=8.52u w=8u l=0.28u
X137 XFE_O.DN.t5 XFE_O.XN.t48 VDD.t58 VDD.t57 pfet_03v3 ad=2.08p pd=8.52u as=2.08p ps=8.52u w=8u l=0.28u
X138 FE_E_N.t4 XFE_E.H.t24 VDD.t43 VDD.t42 pfet_03v3 ad=2.08p pd=8.52u as=3.52p ps=16.88u w=8u l=0.28u
X139 a_n5052_2600.t3 RX_BIAS.t10 VSS.t107 VSS.t105 nfet_03v3 ad=0.88p pd=4.88u as=0.52p ps=2.52u w=2u l=0.28u
X140 a_n6572_3500.t3 RXP.t8 a_n5052_n1000.t8 VSS.t188 nfet_03v3 ad=4.4p pd=20.88u as=2.6p ps=10.52u w=10u l=0.28u
X141 a_n6400_n19852.t2 TERM_EN2_N.t0 a_n7300_n19900.t3 VDD.t70 pfet_03v3 ad=2.6p pd=10.52u as=4.4p ps=20.88u w=10u l=0.28u
X142 a_n3600_5641.t4 VTHN.t0 a_n5052_2600.t6 VSS.t213 nfet_03v3 ad=0.88p pd=4.88u as=0.52p ps=2.52u w=2u l=0.28u
X143 XFE_E.NIN.t19 RX_RAWP.t12 XFE_E.NTAIL.t39 VSS.t242 nfet_03v3 ad=3.52p pd=16.88u as=2.08p ps=8.52u w=8u l=0.28u
X144 XFE_O.NIN.t13 RX_RAWN.t6 XFE_O.NTAIL.t5 VSS.t92 nfet_03v3 ad=2.08p pd=8.52u as=2.08p ps=8.52u w=8u l=0.28u
X145 XFE_O.NIP.t10 XFE_O.XN.t37 XFE_O.XP.t11 VSS.t186 nfet_03v3 ad=2.08p pd=8.52u as=2.08p ps=8.52u w=8u l=0.28u
X146 XFE_O.NIP.t15 O_SENSE_CLK.t27 VDD.t125 VDD.t124 pfet_03v3 ad=3.52p pd=16.88u as=2.08p ps=8.52u w=8u l=0.28u
X147 a_n7157_n23500.t3 TERM_EN0_N.t1 a_n6400_n23452.t3 VDD.t302 pfet_03v3 ad=4.4p pd=20.88u as=2.6p ps=10.52u w=10u l=0.28u
X148 XFE_O.NTAIL.t26 O_SENSE_BOOST.t18 VSS.t318 VSS.t317 nfet_03v3 ad=2.6p pd=10.52u as=2.6p ps=10.52u w=10u l=0.28u
X149 VDD.t15 XFE_E.H.t26 XFE_E.HB.t15 VDD.t14 pfet_03v3 ad=2.08p pd=8.52u as=2.08p ps=8.52u w=8u l=0.28u
X150 VDD.t257 E_SENSE_CLK.t10 XFE_E.XP.t18 VDD.t256 pfet_03v3 ad=2.08p pd=8.52u as=2.08p ps=8.52u w=8u l=0.28u
X151 RXP.t0 a_n7300_n19900.t1 VSS.t77 ppolyf_u r_width=1u r_length=1u
X152 VSS.t66 XFE_O.H.t17 XFE_O.HB.t2 VSS.t65 nfet_03v3 ad=3.52p pd=16.88u as=3.52p ps=16.88u w=8u l=0.28u
X153 VDD.t62 RX_RAWN.t2 VSS.t78 ppolyf_u r_width=2u r_length=3.43u
X154 XFE_E.HB.t1 XFE_E.XP.t54 VDD.t35 VDD.t34 pfet_03v3 ad=2.08p pd=8.52u as=2.08p ps=8.52u w=8u l=0.28u
X155 a_n7300_n14500.t0 a_n10800_n14372.t3 a_n6400_n14452.t0 VSS.t64 nfet_03v3 ad=4.4p pd=20.88u as=2.6p ps=10.52u w=10u l=0.28u
X156 a_n10800_n12572.t0 TERM_EN6_N.t2 VSS.t3 VSS.t2 nfet_03v3 ad=0.44p pd=2.88u as=0.44p ps=2.88u w=1u l=0.28u
X157 XFE_E.NTAIL.t44 E_SENSE_CLK.t0 VSS.t282 VSS.t281 nfet_03v3 ad=4.4p pd=20.88u as=2.6p ps=10.52u w=10u l=0.28u
X158 VSS.t234 XFE_E.DN.t13 XFE_E.HB.t3 VSS.t233 nfet_03v3 ad=2.08p pd=8.52u as=3.52p ps=16.88u w=8u l=0.28u
X159 XFE_E.NTAIL.t33 RX_RAWP.t15 XFE_E.NIN.t16 VSS.t239 nfet_03v3 ad=2.08p pd=8.52u as=2.08p ps=8.52u w=8u l=0.28u
X160 XFE_O.XP.t23 O_SENSE_CLK.t39 VDD.t99 VDD.t98 pfet_03v3 ad=2.08p pd=8.52u as=2.08p ps=8.52u w=8u l=0.28u
X161 VSS.t112 RX_BIAS.t0 a_2148_n500.t5 VSS.t99 nfet_03v3 ad=4.4p pd=20.88u as=2.6p ps=10.52u w=10u l=0.28u
X162 VSS.t278 E_SENSE_CLK.t3 XFE_E.NTAIL.t41 VSS.t277 nfet_03v3 ad=2.6p pd=10.52u as=2.6p ps=10.52u w=10u l=0.28u
X163 a_n10800_n21572.t1 TERM_EN1_N.t3 VDD.t25 VDD.t24 pfet_03v3 ad=0.88p pd=4.88u as=0.88p ps=4.88u w=2u l=0.28u
X164 VSS.t106 RX_BIAS.t11 a_n5052_2600.t2 VSS.t105 nfet_03v3 ad=0.52p pd=2.52u as=0.52p ps=2.52u w=2u l=0.28u
X165 a_n5052_n1000.t7 RXP.t9 a_n6572_3500.t2 VSS.t188 nfet_03v3 ad=2.6p pd=10.52u as=4.4p ps=20.88u w=10u l=0.28u
X166 XFE_E.NIP.t15 XFE_E.XN.t35 XFE_E.XP.t8 VSS.t179 nfet_03v3 ad=2.08p pd=8.52u as=2.08p ps=8.52u w=8u l=0.28u
X167 VSS.t25 XFE_O.H.t19 FE_O_P.t1 VSS.t24 nfet_03v3 ad=2.08p pd=8.52u as=2.08p ps=8.52u w=8u l=0.28u
X168 XFE_O.HB.t8 XFE_O.DN.t10 VSS.t359 VSS.t358 nfet_03v3 ad=2.08p pd=8.52u as=2.08p ps=8.52u w=8u l=0.28u
X169 XFE_O.NIP.t7 XFE_O.XN.t43 XFE_O.XP.t8 VSS.t57 nfet_03v3 ad=2.08p pd=8.52u as=3.52p ps=16.88u w=8u l=0.28u
X170 VDD.t29 XFE_E.XN.t47 XFE_E.DN.t2 VDD.t28 pfet_03v3 ad=2.08p pd=8.52u as=2.08p ps=8.52u w=8u l=0.28u
X171 XFE_O.XN.t9 O_SENSE_CLK.t5 VDD.t159 VDD.t158 pfet_03v3 ad=3.52p pd=16.88u as=2.08p ps=8.52u w=8u l=0.28u
X172 XFE_E.NIP.t11 RX_RAWN.t14 XFE_E.NTAIL.t1 VSS.t84 nfet_03v3 ad=2.08p pd=8.52u as=2.08p ps=8.52u w=8u l=0.28u
X173 VSS.t124 XFE_E.HB.t21 FE_E_P.t4 VSS.t123 nfet_03v3 ad=2.08p pd=8.52u as=3.52p ps=16.88u w=8u l=0.28u
X174 VDD.t135 O_SENSE_CLK.t18 XFE_O.NIN.t18 VDD.t134 pfet_03v3 ad=2.08p pd=8.52u as=3.52p ps=16.88u w=8u l=0.28u
X175 a_n7300_n18100.t1 a_n10800_n17972.t3 a_n6400_n18052.t0 VSS.t253 nfet_03v3 ad=4.4p pd=20.88u as=2.6p ps=10.52u w=10u l=0.28u
X176 XFE_E.XN.t30 E_SENSE_CLK.t20 XFE_E.XP.t30 VDD.t236 pfet_03v3 ad=2.08p pd=8.52u as=2.08p ps=8.52u w=8u l=0.28u
X177 a_n6400_n21652.t1 TERM_EN1_N.t0 a_n7157_n21700.t1 VDD.t27 pfet_03v3 ad=2.6p pd=10.52u as=4.4p ps=20.88u w=10u l=0.28u
X178 a_n6400_n21652.t2 RXN.t1 VSS.t121 ppolyf_u r_width=1u r_length=2.43u
X179 XFE_E.XP.t5 XFE_E.XN.t38 XFE_E.NIP.t16 VSS.t189 nfet_03v3 ad=2.08p pd=8.52u as=2.08p ps=8.52u w=8u l=0.28u
X180 XFE_O.DP.t0 XFE_O.XP.t48 VDD.t189 VDD.t188 pfet_03v3 ad=2.08p pd=8.52u as=2.08p ps=8.52u w=8u l=0.28u
X181 VSS.t223 O_SENSE_CLK.t2 XFE_O.NTAIL.t10 VSS.t222 nfet_03v3 ad=2.6p pd=10.52u as=2.6p ps=10.52u w=10u l=0.28u
X182 VDD.t119 O_SENSE_CLK.t30 XFE_O.NIP.t12 VDD.t118 pfet_03v3 ad=2.08p pd=8.52u as=3.52p ps=16.88u w=8u l=0.28u
X183 a_n6400_n12652.t3 a_n10800_n12572.t2 a_n7300_n12700.t4 VSS.t212 nfet_03v3 ad=2.6p pd=10.52u as=4.4p ps=20.88u w=10u l=0.28u
X184 XFE_O.NTAIL.t34 O_SENSE_BOOST.t10 VSS.t334 VSS.t333 nfet_03v3 ad=2.6p pd=10.52u as=2.6p ps=10.52u w=10u l=0.28u
X185 XFE_O.NTAIL.t13 RX_RAWP.t11 XFE_O.NIP.t16 VSS.t243 nfet_03v3 ad=2.08p pd=8.52u as=3.52p ps=16.88u w=8u l=0.28u
X186 XFE_O.DN.t3 XFE_O.XN.t44 VSS.t59 VSS.t58 nfet_03v3 ad=3.52p pd=16.88u as=2.08p ps=8.52u w=8u l=0.28u
X187 XFE_E.NTAIL.t13 E_SENSE_BOOST.t18 VSS.t136 VSS.t135 nfet_03v3 ad=2.6p pd=10.52u as=2.6p ps=10.52u w=10u l=0.28u
X188 XFE_O.NIN.t21 O_SENSE_CLK.t15 VDD.t139 VDD.t138 pfet_03v3 ad=3.52p pd=16.88u as=2.08p ps=8.52u w=8u l=0.28u
X189 XFE_E.XP.t21 E_SENSE_CLK.t7 VDD.t261 VDD.t260 pfet_03v3 ad=2.08p pd=8.52u as=2.08p ps=8.52u w=8u l=0.28u
X190 XFE_E.XP.t27 E_SENSE_CLK.t23 XFE_E.XN.t14 VDD.t233 pfet_03v3 ad=2.08p pd=8.52u as=2.08p ps=8.52u w=8u l=0.28u
X191 XFE_O.H.t6 XFE_O.DP.t8 VSS.t200 VSS.t199 nfet_03v3 ad=2.08p pd=8.52u as=2.08p ps=8.52u w=8u l=0.28u
X192 a_n10800_n16172.t0 TERM_EN4_N.t2 VSS.t254 VSS.t2 nfet_03v3 ad=0.44p pd=2.88u as=0.44p ps=2.88u w=1u l=0.28u
X193 XFE_E.NIN.t10 XFE_E.XP.t33 XFE_E.XN.t11 VSS.t214 nfet_03v3 ad=2.08p pd=8.52u as=2.08p ps=8.52u w=8u l=0.28u
X194 XFE_O.XN.t10 O_SENSE_CLK.t26 XFE_O.XP.t17 VDD.t126 pfet_03v3 ad=2.08p pd=8.52u as=3.52p ps=16.88u w=8u l=0.28u
X195 VSS.t130 E_SENSE_BOOST.t21 XFE_E.NTAIL.t10 VSS.t129 nfet_03v3 ad=2.6p pd=10.52u as=2.6p ps=10.52u w=10u l=0.28u
X196 XFE_E.XP.t11 XFE_E.XN.t32 XFE_E.NIP.t2 VSS.t38 nfet_03v3 ad=3.52p pd=16.88u as=2.08p ps=8.52u w=8u l=0.28u
X197 XFE_O.H.t14 XFE_O.HB.t27 VDD.t283 VDD.t282 pfet_03v3 ad=2.08p pd=8.52u as=2.08p ps=8.52u w=8u l=0.28u
X198 XFE_O.XN.t27 XFE_O.XP.t34 XFE_O.NIN.t4 VSS.t44 nfet_03v3 ad=2.08p pd=8.52u as=2.08p ps=8.52u w=8u l=0.28u
X199 VDD.t81 XFE_O.H.t26 FE_O_P.t4 VDD.t80 pfet_03v3 ad=3.52p pd=16.88u as=2.08p ps=8.52u w=8u l=0.28u
X200 VDD.t205 E_SENSE_CLK.t40 XFE_E.XN.t19 VDD.t204 pfet_03v3 ad=2.08p pd=8.52u as=3.52p ps=16.88u w=8u l=0.28u
X201 XFE_O.NIP.t0 XFE_O.XN.t35 XFE_O.XP.t0 VSS.t7 nfet_03v3 ad=2.08p pd=8.52u as=2.08p ps=8.52u w=8u l=0.28u
X202 XFE_E.H.t8 XFE_E.XN.t52 VDD.t201 VDD.t200 pfet_03v3 ad=2.08p pd=8.52u as=2.08p ps=8.52u w=8u l=0.28u
X203 XFE_O.NTAIL.t28 O_SENSE_BOOST.t16 VSS.t322 VSS.t321 nfet_03v3 ad=2.6p pd=10.52u as=2.6p ps=10.52u w=10u l=0.28u
X204 VSS.t14 XFE_E.DP.t9 XFE_E.H.t13 VSS.t13 nfet_03v3 ad=2.08p pd=8.52u as=2.08p ps=8.52u w=8u l=0.28u
X205 FE_E_P.t6 XFE_E.HB.t18 VSS.t285 VSS.t284 nfet_03v3 ad=3.52p pd=16.88u as=2.08p ps=8.52u w=8u l=0.28u
X206 a_2148_n500.t8 a_n3600_5641.t7 RX_RAWN.t3 VSS.t4 nfet_03v3 ad=1.3p pd=5.52u as=2.2p ps=10.88u w=5u l=0.28u
X207 a_n10800_n19772.t0 TERM_EN2_N.t2 VSS.t96 VSS.t2 nfet_03v3 ad=0.44p pd=2.88u as=0.44p ps=2.88u w=1u l=0.28u
X208 XFE_E.NTAIL.t37 RX_RAWP.t17 XFE_E.NIN.t14 VSS.t237 nfet_03v3 ad=2.08p pd=8.52u as=2.08p ps=8.52u w=8u l=0.28u
X209 VSS.t37 XFE_E.XN.t45 XFE_E.DN.t4 VSS.t36 nfet_03v3 ad=2.08p pd=8.52u as=3.52p ps=16.88u w=8u l=0.28u
X210 XFE_E.NTAIL.t29 E_SENSE_BOOST.t2 VSS.t166 VSS.t165 nfet_03v3 ad=2.6p pd=10.52u as=2.6p ps=10.52u w=10u l=0.28u
X211 XFE_O.H.t11 XFE_O.XN.t54 VDD.t166 VDD.t165 pfet_03v3 ad=2.08p pd=8.52u as=2.08p ps=8.52u w=8u l=0.28u
X212 XFE_O.HB.t13 XFE_O.XP.t52 VDD.t193 VDD.t192 pfet_03v3 ad=2.08p pd=8.52u as=2.08p ps=8.52u w=8u l=0.28u
X213 XFE_O.XP.t7 XFE_O.XN.t32 XFE_O.NIP.t6 VSS.t48 nfet_03v3 ad=3.52p pd=16.88u as=2.08p ps=8.52u w=8u l=0.28u
X214 VSS.t330 O_SENSE_BOOST.t13 XFE_O.NTAIL.t31 VSS.t329 nfet_03v3 ad=2.6p pd=10.52u as=2.6p ps=10.52u w=10u l=0.28u
X215 VSS.t140 E_SENSE_BOOST.t15 XFE_E.NTAIL.t16 VSS.t139 nfet_03v3 ad=2.6p pd=10.52u as=2.6p ps=10.52u w=10u l=0.28u
X216 XFE_E.H.t10 XFE_E.DP.t12 VSS.t116 VSS.t115 nfet_03v3 ad=2.08p pd=8.52u as=2.08p ps=8.52u w=8u l=0.28u
X217 XFE_O.XN.t21 XFE_O.XP.t40 XFE_O.NIN.t16 VSS.t216 nfet_03v3 ad=2.08p pd=8.52u as=2.08p ps=8.52u w=8u l=0.28u
X218 a_n6400_n16252.t1 a_n10800_n16172.t2 a_n7300_n16300.t1 VSS.t201 nfet_03v3 ad=2.6p pd=10.52u as=4.4p ps=20.88u w=10u l=0.28u
X219 VDD.t217 E_SENSE_CLK.t34 XFE_E.XN.t25 VDD.t216 pfet_03v3 ad=2.08p pd=8.52u as=2.08p ps=8.52u w=8u l=0.28u
X220 VDD.t295 XFE_O.XP.t47 XFE_O.DP.t3 VDD.t294 pfet_03v3 ad=2.08p pd=8.52u as=2.08p ps=8.52u w=8u l=0.28u
X221 XFE_O.NTAIL.t22 O_SENSE_BOOST.t22 VSS.t310 VSS.t309 nfet_03v3 ad=2.6p pd=10.52u as=2.6p ps=10.52u w=10u l=0.28u
X222 VSS.t230 XFE_O.DP.t11 XFE_O.H.t3 VSS.t229 nfet_03v3 ad=2.08p pd=8.52u as=2.08p ps=8.52u w=8u l=0.28u
X223 XFE_E.HB.t12 XFE_E.H.t21 VSS.t29 VSS.t28 nfet_03v3 ad=3.52p pd=16.88u as=3.52p ps=16.88u w=8u l=0.28u
X224 XFE_E.HB.t10 XFE_E.DN.t6 VSS.t118 VSS.t117 nfet_03v3 ad=3.52p pd=16.88u as=2.08p ps=8.52u w=8u l=0.28u
X225 RXP.t7 a_n7157_n21700.t3 VSS.t77 ppolyf_u r_width=1u r_length=2.43u
X226 XFE_O.NIN.t7 XFE_O.XP.t37 XFE_O.XN.t24 VSS.t54 nfet_03v3 ad=2.08p pd=8.52u as=2.08p ps=8.52u w=8u l=0.28u
X227 RXP.t5 RXN.t6 VSS.t268 ppolyf_u r_width=4u r_length=1.23u
X228 XFE_O.XN.t1 O_SENSE_CLK.t13 VDD.t141 VDD.t140 pfet_03v3 ad=2.08p pd=8.52u as=2.08p ps=8.52u w=8u l=0.28u
X229 XFE_O.NTAIL.t4 RX_RAWN.t7 XFE_O.NIN.t12 VSS.t91 nfet_03v3 ad=2.08p pd=8.52u as=2.08p ps=8.52u w=8u l=0.28u
X230 XFE_E.XN.t22 E_SENSE_CLK.t37 VDD.t209 VDD.t208 pfet_03v3 ad=2.08p pd=8.52u as=2.08p ps=8.52u w=8u l=0.28u
X231 XFE_O.XP.t12 XFE_O.XN.t38 XFE_O.NIP.t11 VSS.t187 nfet_03v3 ad=2.08p pd=8.52u as=2.08p ps=8.52u w=8u l=0.28u
X232 VDD.t123 O_SENSE_CLK.t28 XFE_O.NIP.t14 VDD.t122 pfet_03v3 ad=2.08p pd=8.52u as=2.08p ps=8.52u w=8u l=0.28u
X233 VSS.t316 O_SENSE_BOOST.t19 XFE_O.NTAIL.t25 VSS.t315 nfet_03v3 ad=2.6p pd=10.52u as=2.6p ps=10.52u w=10u l=0.28u
X234 XFE_E.XP.t19 E_SENSE_CLK.t9 VDD.t259 VDD.t258 pfet_03v3 ad=2.08p pd=8.52u as=2.08p ps=8.52u w=8u l=0.28u
X235 a_n6400_n19852.t1 a_n10800_n19772.t2 a_n7300_n19900.t0 VSS.t69 nfet_03v3 ad=2.6p pd=10.52u as=4.4p ps=20.88u w=10u l=0.28u
X236 XFE_E.NTAIL.t3 RX_RAWN.t19 XFE_E.NIP.t6 VSS.t79 nfet_03v3 ad=2.08p pd=8.52u as=3.52p ps=16.88u w=8u l=0.28u
X237 FE_E_P.t1 XFE_E.HB.t26 VDD.t7 VDD.t6 pfet_03v3 ad=3.52p pd=16.88u as=2.08p ps=8.52u w=8u l=0.28u
X238 XFE_E.NIP.t1 XFE_E.XN.t43 XFE_E.XP.t0 VSS.t27 nfet_03v3 ad=2.08p pd=8.52u as=3.52p ps=16.88u w=8u l=0.28u
X239 a_n7157_n23500.t0 a_n10800_n23372.t3 a_n6400_n23452.t0 VSS.t95 nfet_03v3 ad=4.4p pd=20.88u as=2.6p ps=10.52u w=10u l=0.28u
X240 a_n10800_n21572.t0 TERM_EN1_N.t2 VSS.t21 VSS.t2 nfet_03v3 ad=0.44p pd=2.88u as=0.44p ps=2.88u w=1u l=0.28u
X241 XFE_O.NIN.t15 RX_RAWN.t4 XFE_O.NTAIL.t7 VSS.t94 nfet_03v3 ad=3.52p pd=16.88u as=2.08p ps=8.52u w=8u l=0.28u
X242 XFE_E.NIN.t17 RX_RAWP.t14 XFE_E.NTAIL.t34 VSS.t240 nfet_03v3 ad=2.08p pd=8.52u as=2.08p ps=8.52u w=8u l=0.28u
X243 VSS.t109 RX_BIAS.t5 a_n5052_n1000.t6 VSS.t99 nfet_03v3 ad=4.4p pd=20.88u as=2.6p ps=10.52u w=10u l=0.28u
X244 XFE_E.NIN.t6 XFE_E.XP.t35 XFE_E.XN.t6 VSS.t180 nfet_03v3 ad=2.08p pd=8.52u as=2.08p ps=8.52u w=8u l=0.28u
X245 FE_E_N.t1 XFE_E.H.t19 VSS.t31 VSS.t30 nfet_03v3 ad=2.08p pd=8.52u as=2.08p ps=8.52u w=8u l=0.28u
X246 a_n7300_n12700.t0 TERM_EN6_N.t1 a_n6400_n12652.t0 VDD.t2 pfet_03v3 ad=4.4p pd=20.88u as=2.6p ps=10.52u w=10u l=0.28u
X247 XFE_O.NIP.t21 RX_RAWP.t6 XFE_O.NTAIL.t18 VSS.t248 nfet_03v3 ad=2.08p pd=8.52u as=2.08p ps=8.52u w=8u l=0.28u
X248 VSS.t126 E_SENSE_BOOST.t23 XFE_E.NTAIL.t8 VSS.t125 nfet_03v3 ad=2.6p pd=10.52u as=4.4p ps=20.88u w=10u l=0.28u
X249 XFE_O.XN.t31 XFE_O.XP.t54 VDD.t285 VDD.t284 pfet_03v3 ad=3.52p pd=16.88u as=2.08p ps=8.52u w=8u l=0.28u
X250 VDD.t170 XFE_E.H.t28 XFE_E.HB.t13 VDD.t169 pfet_03v3 ad=2.08p pd=8.52u as=3.52p ps=16.88u w=8u l=0.28u
X251 VDD.t253 E_SENSE_CLK.t12 XFE_E.XP.t16 VDD.t252 pfet_03v3 ad=2.08p pd=8.52u as=2.08p ps=8.52u w=8u l=0.28u
X252 a_n5052_n1000.t0 RXN.t9 a_n3600_5641.t0 VSS.t4 nfet_03v3 ad=2.6p pd=10.52u as=4.4p ps=20.88u w=10u l=0.28u
X253 FE_O_P.t2 XFE_O.H.t20 VSS.t71 VSS.t70 nfet_03v3 ad=2.08p pd=8.52u as=2.08p ps=8.52u w=8u l=0.28u
X254 XFE_O.NIN.t23 XFE_O.XP.t43 XFE_O.XN.t18 VSS.t306 nfet_03v3 ad=2.08p pd=8.52u as=3.52p ps=16.88u w=8u l=0.28u
X255 XFE_O.XP.t25 O_SENSE_CLK.t37 VDD.t105 VDD.t104 pfet_03v3 ad=2.08p pd=8.52u as=2.08p ps=8.52u w=8u l=0.28u
X256 XFE_E.XN.t1 XFE_E.XP.t38 XFE_E.NIN.t1 VSS.t35 nfet_03v3 ad=2.08p pd=8.52u as=2.08p ps=8.52u w=8u l=0.28u
X257 XFE_O.XP.t20 O_SENSE_CLK.t21 XFE_O.XN.t15 VDD.t131 pfet_03v3 ad=2.08p pd=8.52u as=2.08p ps=8.52u w=8u l=0.28u
X258 XFE_E.NIP.t19 XFE_E.XN.t37 XFE_E.XP.t6 VSS.t194 nfet_03v3 ad=2.08p pd=8.52u as=2.08p ps=8.52u w=8u l=0.28u
X259 XFE_E.NTAIL.t27 E_SENSE_BOOST.t4 VSS.t162 VSS.t161 nfet_03v3 ad=2.6p pd=10.52u as=2.6p ps=10.52u w=10u l=0.28u
X260 XFE_O.NIN.t9 RX_RAWN.t10 XFE_O.NTAIL.t1 VSS.t88 nfet_03v3 ad=2.08p pd=8.52u as=2.08p ps=8.52u w=8u l=0.28u
X261 a_n6400_n14452.t1 RXN.t2 VSS.t122 ppolyf_u r_width=1u r_length=1u
X262 VDD.t39 XFE_E.XN.t49 XFE_E.DN.t3 VDD.t38 pfet_03v3 ad=2.08p pd=8.52u as=3.52p ps=16.88u w=8u l=0.28u
X263 VSS.t6 XFE_O.XN.t45 XFE_O.DN.t0 VSS.t5 nfet_03v3 ad=2.08p pd=8.52u as=3.52p ps=16.88u w=8u l=0.28u
X264 VSS.t294 XFE_O.HB.t20 FE_O_N.t3 VSS.t293 nfet_03v3 ad=2.08p pd=8.52u as=3.52p ps=16.88u w=8u l=0.28u
X265 a_n6400_n21652.t4 a_n10800_n21572.t2 a_n7157_n21700.t4 VSS.t298 nfet_03v3 ad=2.6p pd=10.52u as=4.4p ps=20.88u w=10u l=0.28u
X266 VDD.t111 O_SENSE_CLK.t34 XFE_O.XP.t28 VDD.t110 pfet_03v3 ad=2.08p pd=8.52u as=2.08p ps=8.52u w=8u l=0.28u
X267 VDD.t263 E_SENSE_CLK.t6 XFE_E.XP.t22 VDD.t262 pfet_03v3 ad=2.08p pd=8.52u as=2.08p ps=8.52u w=8u l=0.28u
X268 VDD.t101 O_SENSE_CLK.t16 XFE_O.NIN.t20 VDD.t100 pfet_03v3 ad=2.08p pd=8.52u as=2.08p ps=8.52u w=8u l=0.28u
X269 VSS.t261 XFE_E.DN.t7 XFE_E.HB.t9 VSS.t260 nfet_03v3 ad=2.08p pd=8.52u as=2.08p ps=8.52u w=8u l=0.28u
X270 VDD.t48 a_n6572_3500.t0 VSS.t50 ppolyf_u r_width=2u r_length=4.57u
X271 XFE_E.XN.t15 E_SENSE_CLK.t22 XFE_E.XP.t28 VDD.t234 pfet_03v3 ad=2.08p pd=8.52u as=2.08p ps=8.52u w=8u l=0.28u
X272 XFE_O.XP.t31 O_SENSE_CLK.t31 VDD.t117 VDD.t116 pfet_03v3 ad=3.52p pd=16.88u as=2.08p ps=8.52u w=8u l=0.28u
X273 XFE_E.XP.t3 XFE_E.XN.t40 XFE_E.NIP.t4 VSS.t67 nfet_03v3 ad=2.08p pd=8.52u as=2.08p ps=8.52u w=8u l=0.28u
X274 VDD.t184 a_5300_5958.t1 VSS.t256 ppolyf_u r_width=1u r_length=1.4u
X275 VSS.t156 E_SENSE_BOOST.t7 XFE_E.NTAIL.t24 VSS.t155 nfet_03v3 ad=2.6p pd=10.52u as=2.6p ps=10.52u w=10u l=0.28u
X276 VSS.t227 O_SENSE_CLK.t0 XFE_O.NTAIL.t12 VSS.t226 nfet_03v3 ad=4.4p pd=20.88u as=2.6p ps=10.52u w=10u l=0.28u
X277 XFE_O.NTAIL.t36 O_SENSE_BOOST.t8 VSS.t338 VSS.t337 nfet_03v3 ad=2.6p pd=10.52u as=2.6p ps=10.52u w=10u l=0.28u
X278 XFE_E.XN.t8 XFE_E.XP.t32 XFE_E.NIN.t8 VSS.t183 nfet_03v3 ad=3.52p pd=16.88u as=2.08p ps=8.52u w=8u l=0.28u
X279 XFE_O.NTAIL.t15 RX_RAWP.t9 XFE_O.NIP.t18 VSS.t245 nfet_03v3 ad=2.08p pd=8.52u as=2.08p ps=8.52u w=8u l=0.28u
X280 FE_O_N.t0 XFE_O.HB.t17 VSS.t263 VSS.t262 nfet_03v3 ad=3.52p pd=16.88u as=2.08p ps=8.52u w=8u l=0.28u
X281 XFE_E.NTAIL.t11 E_SENSE_BOOST.t20 VSS.t132 VSS.t131 nfet_03v3 ad=2.6p pd=10.52u as=2.6p ps=10.52u w=10u l=0.28u
X282 XFE_E.HB.t16 XFE_E.H.t25 VDD.t13 VDD.t12 pfet_03v3 ad=3.52p pd=16.88u as=2.08p ps=8.52u w=8u l=0.28u
X283 XFE_O.NIN.t5 XFE_O.XP.t35 XFE_O.XN.t26 VSS.t45 nfet_03v3 ad=2.08p pd=8.52u as=2.08p ps=8.52u w=8u l=0.28u
X284 XFE_E.HB.t6 XFE_E.DN.t10 VSS.t259 VSS.t258 nfet_03v3 ad=2.08p pd=8.52u as=2.08p ps=8.52u w=8u l=0.28u
X285 FE_O_P.t5 XFE_O.H.t27 VDD.t83 VDD.t82 pfet_03v3 ad=2.08p pd=8.52u as=2.08p ps=8.52u w=8u l=0.28u
X286 XFE_E.XN.t20 E_SENSE_CLK.t39 VDD.t207 VDD.t206 pfet_03v3 ad=2.08p pd=8.52u as=2.08p ps=8.52u w=8u l=0.28u
X287 XFE_O.XP.t2 XFE_O.XN.t50 VDD.t23 VDD.t22 pfet_03v3 ad=3.52p pd=16.88u as=2.08p ps=8.52u w=8u l=0.28u
X288 XFE_E.XP.t25 E_SENSE_CLK.t25 XFE_E.XN.t16 VDD.t231 pfet_03v3 ad=2.08p pd=8.52u as=2.08p ps=8.52u w=8u l=0.28u
X289 a_n7300_n16300.t2 TERM_EN4_N.t1 a_n6400_n16252.t3 VDD.t178 pfet_03v3 ad=4.4p pd=20.88u as=2.6p ps=10.52u w=10u l=0.28u
X290 VDD.t33 XFE_E.XP.t53 XFE_E.HB.t0 VDD.t32 pfet_03v3 ad=2.08p pd=8.52u as=2.08p ps=8.52u w=8u l=0.28u
X291 VDD.t197 XFE_E.XN.t51 XFE_E.H.t7 VDD.t196 pfet_03v3 ad=2.08p pd=8.52u as=2.08p ps=8.52u w=8u l=0.28u
X292 XFE_O.H.t8 XFE_O.DP.t6 VSS.t198 VSS.t197 nfet_03v3 ad=3.52p pd=16.88u as=2.08p ps=8.52u w=8u l=0.28u
X293 XFE_E.H.t14 XFE_E.DP.t8 VSS.t174 VSS.t173 nfet_03v3 ad=2.08p pd=8.52u as=2.08p ps=8.52u w=8u l=0.28u
X294 VDD.t97 O_SENSE_CLK.t40 XFE_O.XP.t22 VDD.t96 pfet_03v3 ad=2.08p pd=8.52u as=3.52p ps=16.88u w=8u l=0.28u
X295 FE_E_P.t0 XFE_E.HB.t28 VDD.t5 VDD.t4 pfet_03v3 ad=2.08p pd=8.52u as=3.52p ps=16.88u w=8u l=0.28u
X296 VSS.t367 XFE_O.DN.t13 XFE_O.HB.t5 VSS.t366 nfet_03v3 ad=2.08p pd=8.52u as=3.52p ps=16.88u w=8u l=0.28u
X297 VSS.t296 XFE_O.HB.t21 XFE_O.H.t12 VSS.t295 nfet_03v3 ad=3.52p pd=16.88u as=3.52p ps=16.88u w=8u l=0.28u
X298 VSS.t342 O_SENSE_BOOST.t5 XFE_O.NTAIL.t39 VSS.t341 nfet_03v3 ad=2.6p pd=10.52u as=2.6p ps=10.52u w=10u l=0.28u
X299 XFE_O.XN.t12 O_SENSE_CLK.t24 XFE_O.XP.t19 VDD.t128 pfet_03v3 ad=2.08p pd=8.52u as=2.08p ps=8.52u w=8u l=0.28u
X300 XFE_E.XP.t9 XFE_E.XN.t34 XFE_E.NIP.t14 VSS.t178 nfet_03v3 ad=2.08p pd=8.52u as=2.08p ps=8.52u w=8u l=0.28u
X301 XFE_O.XN.t29 XFE_O.XP.t32 XFE_O.NIN.t2 VSS.t15 nfet_03v3 ad=3.52p pd=16.88u as=2.08p ps=8.52u w=8u l=0.28u
X302 a_n10800_n14372.t1 TERM_EN5_N.t3 VDD.t181 VDD.t180 pfet_03v3 ad=0.88p pd=4.88u as=0.88p ps=4.88u w=2u l=0.28u
X303 XFE_E.DN.t1 XFE_E.XN.t44 VSS.t10 VSS.t9 nfet_03v3 ad=3.52p pd=16.88u as=2.08p ps=8.52u w=8u l=0.28u
X304 XFE_E.DP.t3 XFE_E.XP.t48 VDD.t91 VDD.t90 pfet_03v3 ad=2.08p pd=8.52u as=2.08p ps=8.52u w=8u l=0.28u
X305 VDD.t153 O_SENSE_CLK.t8 XFE_O.XN.t6 VDD.t152 pfet_03v3 ad=2.08p pd=8.52u as=2.08p ps=8.52u w=8u l=0.28u
X306 VSS.t168 E_SENSE_BOOST.t1 XFE_E.NTAIL.t30 VSS.t167 nfet_03v3 ad=2.6p pd=10.52u as=2.6p ps=10.52u w=10u l=0.28u
X307 VSS.t108 RX_BIAS.t7 a_n5052_n1000.t4 VSS.t101 nfet_03v3 ad=2.6p pd=10.52u as=2.6p ps=10.52u w=10u l=0.28u
X308 XFE_O.NIP.t8 XFE_O.XN.t33 XFE_O.XP.t9 VSS.t60 nfet_03v3 ad=2.08p pd=8.52u as=2.08p ps=8.52u w=8u l=0.28u
X309 XFE_E.NIN.t21 E_SENSE_CLK.t29 VDD.t225 VDD.t224 pfet_03v3 ad=2.08p pd=8.52u as=2.08p ps=8.52u w=8u l=0.28u
X310 XFE_O.NTAIL.t30 O_SENSE_BOOST.t14 VSS.t328 VSS.t327 nfet_03v3 ad=2.6p pd=10.52u as=2.6p ps=10.52u w=10u l=0.28u
X311 XFE_E.DN.t5 XFE_E.XN.t46 VDD.t60 VDD.t59 pfet_03v3 ad=3.52p pd=16.88u as=2.08p ps=8.52u w=8u l=0.28u
X312 VSS.t365 XFE_E.DP.t11 XFE_E.H.t11 VSS.t364 nfet_03v3 ad=2.08p pd=8.52u as=2.08p ps=8.52u w=8u l=0.28u
X313 VDD.t277 XFE_O.HB.t24 FE_O_N.t6 VDD.t276 pfet_03v3 ad=2.08p pd=8.52u as=3.52p ps=16.88u w=8u l=0.28u
X314 a_n7300_n19900.t2 TERM_EN2_N.t1 a_n6400_n19852.t3 VDD.t69 pfet_03v3 ad=4.4p pd=20.88u as=2.6p ps=10.52u w=10u l=0.28u
X315 a_n6400_n18052.t2 RXN.t7 VSS.t286 ppolyf_u r_width=1u r_length=1u
X316 VSS.t304 XFE_O.XP.t45 XFE_O.DP.t5 VSS.t303 nfet_03v3 ad=2.08p pd=8.52u as=3.52p ps=16.88u w=8u l=0.28u
X317 XFE_E.NIP.t21 E_SENSE_CLK.t17 VDD.t245 VDD.t244 pfet_03v3 ad=2.08p pd=8.52u as=2.08p ps=8.52u w=8u l=0.28u
X318 XFE_E.NTAIL.t35 RX_RAWP.t19 XFE_E.NIN.t12 VSS.t235 nfet_03v3 ad=2.08p pd=8.52u as=3.52p ps=16.88u w=8u l=0.28u
X319 XFE_O.H.t2 XFE_O.DP.t12 VSS.t363 VSS.t362 nfet_03v3 ad=2.08p pd=8.52u as=2.08p ps=8.52u w=8u l=0.28u
X320 a_n6400_n14452.t4 TERM_EN5_N.t0 a_n7300_n14500.t3 VDD.t183 pfet_03v3 ad=2.6p pd=10.52u as=4.4p ps=20.88u w=10u l=0.28u
X321 RX_RAWP.t3 a_n6572_3500.t6 a_2148_n500.t7 VSS.t4 nfet_03v3 ad=2.2p pd=10.88u as=1.3p ps=5.52u w=5u l=0.28u
X322 VSS.t324 O_SENSE_BOOST.t11 XFE_O.NTAIL.t33 VSS.t323 nfet_03v3 ad=2.6p pd=10.52u as=2.6p ps=10.52u w=10u l=0.28u
X323 VDD.t187 XFE_E.XN.t55 XFE_E.XP.t12 VDD.t186 pfet_03v3 ad=2.08p pd=8.52u as=3.52p ps=16.88u w=8u l=0.28u
X324 XFE_E.H.t1 XFE_E.HB.t24 VDD.t37 VDD.t36 pfet_03v3 ad=2.08p pd=8.52u as=2.08p ps=8.52u w=8u l=0.28u
X325 XFE_O.XN.t23 XFE_O.XP.t38 XFE_O.NIN.t0 VSS.t0 nfet_03v3 ad=2.08p pd=8.52u as=2.08p ps=8.52u w=8u l=0.28u
X326 VDD.t143 O_SENSE_CLK.t14 XFE_O.XN.t0 VDD.t142 pfet_03v3 ad=2.08p pd=8.52u as=3.52p ps=16.88u w=8u l=0.28u
X327 XFE_O.NIN.t11 RX_RAWN.t8 XFE_O.NTAIL.t3 VSS.t90 nfet_03v3 ad=2.08p pd=8.52u as=2.08p ps=8.52u w=8u l=0.28u
X328 RXP.t6 a_n7300_n14500.t4 VSS.t77 ppolyf_u r_width=1u r_length=1u
X329 XFE_O.NIP.t13 O_SENSE_CLK.t29 VDD.t121 VDD.t120 pfet_03v3 ad=2.08p pd=8.52u as=2.08p ps=8.52u w=8u l=0.28u
X330 VSS.t210 XFE_O.DP.t9 XFE_O.H.t5 VSS.t209 nfet_03v3 ad=2.08p pd=8.52u as=2.08p ps=8.52u w=8u l=0.28u
X331 XFE_E.NIN.t9 XFE_E.XP.t43 XFE_E.XN.t10 VSS.t202 nfet_03v3 ad=2.08p pd=8.52u as=3.52p ps=16.88u w=8u l=0.28u
X332 XFE_E.XP.t1 XFE_E.XN.t42 XFE_E.NIP.t0 VSS.t26 nfet_03v3 ad=2.08p pd=8.52u as=2.08p ps=8.52u w=8u l=0.28u
X333 a_n6572_3500.t5 VTHP.t0 a_n5052_2600.t4 VSS.t195 nfet_03v3 ad=0.88p pd=4.88u as=0.52p ps=2.52u w=2u l=0.28u
X334 VSS.t152 E_SENSE_BOOST.t9 XFE_E.NTAIL.t22 VSS.t151 nfet_03v3 ad=2.6p pd=10.52u as=2.6p ps=10.52u w=10u l=0.28u
X335 XFE_O.XN.t3 O_SENSE_CLK.t11 VDD.t149 VDD.t148 pfet_03v3 ad=2.08p pd=8.52u as=2.08p ps=8.52u w=8u l=0.28u
X336 XFE_O.NTAIL.t6 RX_RAWN.t5 XFE_O.NIN.t14 VSS.t93 nfet_03v3 ad=2.08p pd=8.52u as=2.08p ps=8.52u w=8u l=0.28u
X337 a_2148_n500.t2 RX_BIAS.t3 VSS.t100 VSS.t99 nfet_03v3 ad=2.6p pd=10.52u as=2.6p ps=10.52u w=10u l=0.28u
X338 VSS.t372 XFE_E.H.t18 FE_E_N.t6 VSS.t371 nfet_03v3 ad=2.08p pd=8.52u as=2.08p ps=8.52u w=8u l=0.28u
X339 VDD.t287 XFE_O.XP.t55 XFE_O.XN.t30 VDD.t286 pfet_03v3 ad=2.08p pd=8.52u as=3.52p ps=16.88u w=8u l=0.28u
X340 a_n10800_n17972.t1 TERM_EN3_N.t3 VDD.t297 VDD.t296 pfet_03v3 ad=0.88p pd=4.88u as=0.88p ps=4.88u w=2u l=0.28u
X341 VSS.t320 O_SENSE_BOOST.t17 XFE_O.NTAIL.t27 VSS.t319 nfet_03v3 ad=2.6p pd=10.52u as=2.6p ps=10.52u w=10u l=0.28u
X342 XFE_O.NTAIL.t17 RX_RAWP.t7 XFE_O.NIP.t20 VSS.t247 nfet_03v3 ad=2.08p pd=8.52u as=2.08p ps=8.52u w=8u l=0.28u
X343 VDD.t61 a_n1900_5958.t1 VSS.t74 ppolyf_u r_width=1u r_length=1.4u
X344 XFE_E.XP.t17 E_SENSE_CLK.t11 VDD.t255 VDD.t254 pfet_03v3 ad=2.08p pd=8.52u as=2.08p ps=8.52u w=8u l=0.28u
X345 a_n7157_n21700.t0 TERM_EN1_N.t1 a_n6400_n21652.t0 VDD.t26 pfet_03v3 ad=4.4p pd=20.88u as=2.6p ps=10.52u w=10u l=0.28u
X346 VDD.t54 XFE_E.XP.t55 XFE_E.HB.t2 VDD.t53 pfet_03v3 ad=2.08p pd=8.52u as=3.52p ps=16.88u w=8u l=0.28u
X347 VDD.t173 XFE_E.XN.t53 XFE_E.H.t5 VDD.t172 pfet_03v3 ad=2.08p pd=8.52u as=3.52p ps=16.88u w=8u l=0.28u
X348 a_n7300_n12700.t3 a_n10800_n12572.t3 a_n6400_n12652.t2 VSS.t196 nfet_03v3 ad=4.4p pd=20.88u as=2.6p ps=10.52u w=10u l=0.28u
X349 VSS.t280 E_SENSE_CLK.t1 XFE_E.NTAIL.t43 VSS.t279 nfet_03v3 ad=2.6p pd=10.52u as=2.6p ps=10.52u w=10u l=0.28u
X350 XFE_E.NTAIL.t19 E_SENSE_BOOST.t12 VSS.t146 VSS.t145 nfet_03v3 ad=2.6p pd=10.52u as=2.6p ps=10.52u w=10u l=0.28u
X351 VDD.t103 O_SENSE_CLK.t38 XFE_O.XP.t24 VDD.t102 pfet_03v3 ad=2.08p pd=8.52u as=2.08p ps=8.52u w=8u l=0.28u
X352 VSS.t346 O_SENSE_BOOST.t3 XFE_O.NTAIL.t41 VSS.t345 nfet_03v3 ad=2.6p pd=10.52u as=2.6p ps=10.52u w=10u l=0.28u
X353 XFE_E.NIN.t0 XFE_E.XP.t37 XFE_E.XN.t0 VSS.t34 nfet_03v3 ad=2.08p pd=8.52u as=2.08p ps=8.52u w=8u l=0.28u
X354 VDD.t47 XFE_O.H.t25 XFE_O.HB.t1 VDD.t46 pfet_03v3 ad=2.08p pd=8.52u as=3.52p ps=16.88u w=8u l=0.28u
X355 XFE_O.NIP.t23 RX_RAWP.t4 XFE_O.NTAIL.t20 VSS.t250 nfet_03v3 ad=3.52p pd=16.88u as=2.08p ps=8.52u w=8u l=0.28u
X356 VDD.t160 a_n6716_3500.t1 VSS.t228 ppolyf_u r_width=1u r_length=1.4u
X357 XFE_E.XP.t7 XFE_E.XN.t36 XFE_E.NIP.t18 VSS.t193 nfet_03v3 ad=2.08p pd=8.52u as=2.08p ps=8.52u w=8u l=0.28u
X358 VDD.t241 E_SENSE_CLK.t14 XFE_E.XP.t14 VDD.t240 pfet_03v3 ad=2.08p pd=8.52u as=3.52p ps=16.88u w=8u l=0.28u
X359 a_n5052_2600.t5 VTHP.t1 a_n6572_3500.t4 VSS.t195 nfet_03v3 ad=0.52p pd=2.52u as=0.88p ps=4.88u w=2u l=0.28u
X360 a_n6400_n18052.t3 TERM_EN3_N.t0 a_n7300_n18100.t4 VDD.t299 pfet_03v3 ad=2.6p pd=10.52u as=4.4p ps=20.88u w=10u l=0.28u
X361 XFE_O.DP.t4 XFE_O.XP.t44 VSS.t302 VSS.t301 nfet_03v3 ad=3.52p pd=16.88u as=2.08p ps=8.52u w=8u l=0.28u
X362 VSS.t164 E_SENSE_BOOST.t3 XFE_E.NTAIL.t28 VSS.t163 nfet_03v3 ad=2.6p pd=10.52u as=2.6p ps=10.52u w=10u l=0.28u
X363 a_5300_5958.t0 RX_BW_EN_N.t0 RX_RAWN.t0 VDD.t52 pfet_03v3 ad=2.2p pd=10.88u as=2.2p ps=10.88u w=5u l=0.28u
X364 XFE_O.NIN.t19 O_SENSE_CLK.t17 VDD.t137 VDD.t136 pfet_03v3 ad=2.08p pd=8.52u as=2.08p ps=8.52u w=8u l=0.28u
X365 XFE_O.XP.t27 O_SENSE_CLK.t35 VDD.t109 VDD.t108 pfet_03v3 ad=2.08p pd=8.52u as=2.08p ps=8.52u w=8u l=0.28u
X366 VDD.t171 a_n3600_5641.t5 VSS.t251 ppolyf_u r_width=2u r_length=4.57u
X367 RXP.t4 a_n7300_n18100.t0 VSS.t77 ppolyf_u r_width=1u r_length=1u
X368 XFE_O.HB.t10 XFE_O.DN.t8 VSS.t206 VSS.t205 nfet_03v3 ad=2.08p pd=8.52u as=2.08p ps=8.52u w=8u l=0.28u
X369 XFE_E.XP.t29 E_SENSE_CLK.t21 XFE_E.XN.t29 VDD.t235 pfet_03v3 ad=2.08p pd=8.52u as=2.08p ps=8.52u w=8u l=0.28u
X370 XFE_O.NTAIL.t44 O_SENSE_BOOST.t0 VSS.t352 VSS.t351 nfet_03v3 ad=4.4p pd=20.88u as=2.6p ps=10.52u w=10u l=0.28u
X371 XFE_E.XN.t3 XFE_E.XP.t40 XFE_E.NIN.t3 VSS.t52 nfet_03v3 ad=2.08p pd=8.52u as=2.08p ps=8.52u w=8u l=0.28u
X372 XFE_O.NIP.t4 XFE_O.XN.t41 XFE_O.XP.t5 VSS.t46 nfet_03v3 ad=2.08p pd=8.52u as=2.08p ps=8.52u w=8u l=0.28u
X373 XFE_O.HB.t3 XFE_O.H.t22 VDD.t64 VDD.t63 pfet_03v3 ad=3.52p pd=16.88u as=2.08p ps=8.52u w=8u l=0.28u
X374 XFE_O.XP.t18 O_SENSE_CLK.t19 XFE_O.XN.t17 VDD.t133 pfet_03v3 ad=3.52p pd=16.88u as=2.08p ps=8.52u w=8u l=0.28u
X375 XFE_E.NIP.t17 XFE_E.XN.t39 XFE_E.XP.t4 VSS.t190 nfet_03v3 ad=2.08p pd=8.52u as=2.08p ps=8.52u w=8u l=0.28u
X376 XFE_E.NTAIL.t25 E_SENSE_BOOST.t6 VSS.t158 VSS.t157 nfet_03v3 ad=2.6p pd=10.52u as=2.6p ps=10.52u w=10u l=0.28u
X377 VDD.t21 XFE_O.XN.t49 XFE_O.DN.t2 VDD.t20 pfet_03v3 ad=2.08p pd=8.52u as=3.52p ps=16.88u w=8u l=0.28u
X378 VSS.t336 O_SENSE_BOOST.t9 XFE_O.NTAIL.t35 VSS.t335 nfet_03v3 ad=2.6p pd=10.52u as=2.6p ps=10.52u w=10u l=0.28u
X379 VDD.t41 XFE_E.H.t23 FE_E_N.t3 VDD.t40 pfet_03v3 ad=2.08p pd=8.52u as=2.08p ps=8.52u w=8u l=0.28u
X380 XFE_O.NIP.t17 RX_RAWP.t10 XFE_O.NTAIL.t14 VSS.t244 nfet_03v3 ad=2.08p pd=8.52u as=2.08p ps=8.52u w=8u l=0.28u
X381 VSS.t265 XFE_O.HB.t18 FE_O_N.t1 VSS.t264 nfet_03v3 ad=2.08p pd=8.52u as=2.08p ps=8.52u w=8u l=0.28u
X382 a_n3600_5641.t1 RXN.t8 a_n5052_n1000.t1 VSS.t4 nfet_03v3 ad=4.4p pd=20.88u as=2.6p ps=10.52u w=10u l=0.28u
X383 VDD.t251 E_SENSE_CLK.t8 XFE_E.XP.t20 VDD.t250 pfet_03v3 ad=2.08p pd=8.52u as=2.08p ps=8.52u w=8u l=0.28u
X384 VSS.t288 XFE_E.DN.t9 XFE_E.HB.t7 VSS.t287 nfet_03v3 ad=2.08p pd=8.52u as=2.08p ps=8.52u w=8u l=0.28u
X385 VDD.t93 XFE_O.XN.t51 XFE_O.XP.t13 VDD.t92 pfet_03v3 ad=2.08p pd=8.52u as=3.52p ps=16.88u w=8u l=0.28u
X386 XFE_E.XN.t17 E_SENSE_CLK.t24 XFE_E.XP.t26 VDD.t232 pfet_03v3 ad=2.08p pd=8.52u as=2.08p ps=8.52u w=8u l=0.28u
X387 XFE_E.HB.t11 XFE_E.XP.t52 VDD.t79 VDD.t78 pfet_03v3 ad=3.52p pd=16.88u as=2.08p ps=8.52u w=8u l=0.28u
X388 XFE_E.H.t6 XFE_E.XN.t50 VDD.t175 VDD.t174 pfet_03v3 ad=3.52p pd=16.88u as=2.08p ps=8.52u w=8u l=0.28u
X389 VSS.t355 XFE_O.DP.t7 XFE_O.H.t7 VSS.t354 nfet_03v3 ad=2.08p pd=8.52u as=2.08p ps=8.52u w=8u l=0.28u
X390 XFE_O.DN.t1 XFE_O.XN.t46 VDD.t9 VDD.t8 pfet_03v3 ad=3.52p pd=16.88u as=2.08p ps=8.52u w=8u l=0.28u
X391 VDD.t73 RX_RAWP.t2 VSS.t177 ppolyf_u r_width=2u r_length=3.43u
X392 a_n7300_n16300.t4 a_n10800_n16172.t3 a_n6400_n16252.t4 VSS.t283 nfet_03v3 ad=4.4p pd=20.88u as=2.6p ps=10.52u w=10u l=0.28u
X393 XFE_O.NTAIL.t38 O_SENSE_BOOST.t6 VSS.t340 VSS.t58 nfet_03v3 ad=2.6p pd=10.52u as=2.6p ps=10.52u w=10u l=0.28u
X394 XFE_E.XN.t12 XFE_E.XP.t34 XFE_E.NIN.t11 VSS.t215 nfet_03v3 ad=2.08p pd=8.52u as=2.08p ps=8.52u w=8u l=0.28u
X395 XFE_O.XP.t15 O_SENSE_CLK.t25 XFE_O.XN.t11 VDD.t127 pfet_03v3 ad=2.08p pd=8.52u as=2.08p ps=8.52u w=8u l=0.28u
X396 a_n10800_n14372.t0 TERM_EN5_N.t2 VSS.t255 VSS.t2 nfet_03v3 ad=0.44p pd=2.88u as=0.44p ps=2.88u w=1u l=0.28u
X397 XFE_O.NIN.t3 XFE_O.XP.t33 XFE_O.XN.t28 VSS.t16 nfet_03v3 ad=2.08p pd=8.52u as=2.08p ps=8.52u w=8u l=0.28u
X398 XFE_E.HB.t4 XFE_E.DN.t12 VSS.t290 VSS.t289 nfet_03v3 ad=2.08p pd=8.52u as=2.08p ps=8.52u w=8u l=0.28u
X399 VDD.t89 XFE_E.XP.t47 XFE_E.DP.t2 VDD.t88 pfet_03v3 ad=2.08p pd=8.52u as=2.08p ps=8.52u w=8u l=0.28u
X400 XFE_O.XN.t5 O_SENSE_CLK.t9 VDD.t147 VDD.t146 pfet_03v3 ad=2.08p pd=8.52u as=2.08p ps=8.52u w=8u l=0.28u
X401 a_2148_n500.t4 RX_BIAS.t1 VSS.t114 VSS.t99 nfet_03v3 ad=2.6p pd=10.52u as=2.6p ps=10.52u w=10u l=0.28u
X402 XFE_E.NTAIL.t31 E_SENSE_BOOST.t0 VSS.t170 VSS.t169 nfet_03v3 ad=4.4p pd=20.88u as=2.6p ps=10.52u w=10u l=0.28u
X403 a_n5052_n1000.t5 RX_BIAS.t6 VSS.t110 VSS.t99 nfet_03v3 ad=2.6p pd=10.52u as=2.6p ps=10.52u w=10u l=0.28u
X404 a_n10800_n23372.t1 TERM_EN0_N.t3 VDD.t301 VDD.t300 pfet_03v3 ad=0.88p pd=4.88u as=0.88p ps=4.88u w=2u l=0.28u
X405 XFE_E.NTAIL.t42 E_SENSE_CLK.t2 VSS.t274 VSS.t273 nfet_03v3 ad=2.6p pd=10.52u as=2.6p ps=10.52u w=10u l=0.28u
X406 VSS.t33 XFE_E.H.t20 FE_E_N.t2 VSS.t32 nfet_03v3 ad=2.08p pd=8.52u as=3.52p ps=16.88u w=8u l=0.28u
X407 XFE_O.H.t16 XFE_O.HB.t25 VDD.t279 VDD.t278 pfet_03v3 ad=3.52p pd=16.88u as=2.08p ps=8.52u w=8u l=0.28u
X408 VSS.t208 XFE_O.DN.t11 XFE_O.HB.t7 VSS.t207 nfet_03v3 ad=2.08p pd=8.52u as=2.08p ps=8.52u w=8u l=0.28u
X409 XFE_E.XN.t28 E_SENSE_CLK.t31 VDD.t213 VDD.t212 pfet_03v3 ad=3.52p pd=16.88u as=2.08p ps=8.52u w=8u l=0.28u
X410 XFE_O.XN.t14 O_SENSE_CLK.t22 XFE_O.XP.t16 VDD.t130 pfet_03v3 ad=2.08p pd=8.52u as=2.08p ps=8.52u w=8u l=0.28u
X411 VDD.t247 E_SENSE_CLK.t16 XFE_E.NIP.t22 VDD.t246 pfet_03v3 ad=2.08p pd=8.52u as=2.08p ps=8.52u w=8u l=0.28u
X412 VDD.t157 O_SENSE_CLK.t6 XFE_O.XN.t8 VDD.t156 pfet_03v3 ad=2.08p pd=8.52u as=2.08p ps=8.52u w=8u l=0.28u
X413 a_n7300_n19900.t4 a_n10800_n19772.t3 a_n6400_n19852.t4 VSS.t172 nfet_03v3 ad=4.4p pd=20.88u as=2.6p ps=10.52u w=10u l=0.28u
X414 XFE_E.NTAIL.t2 RX_RAWN.t13 XFE_E.NIP.t12 VSS.t85 nfet_03v3 ad=2.08p pd=8.52u as=2.08p ps=8.52u w=8u l=0.28u
X415 FE_E_P.t3 XFE_E.HB.t20 VSS.t56 VSS.t55 nfet_03v3 ad=2.08p pd=8.52u as=2.08p ps=8.52u w=8u l=0.28u
X416 VSS.t103 RX_BIAS.t9 a_n5052_n1000.t2 VSS.t101 nfet_03v3 ad=2.6p pd=10.52u as=4.4p ps=20.88u w=10u l=0.28u
X417 a_n6400_n23452.t1 RXN.t4 VSS.t252 ppolyf_u r_width=1u r_length=2.43u
X418 XFE_E.XP.t13 XFE_E.XN.t54 VDD.t267 VDD.t266 pfet_03v3 ad=3.52p pd=16.88u as=2.08p ps=8.52u w=8u l=0.28u
X419 a_n6400_n23452.t4 TERM_EN0_N.t0 a_n7157_n23500.t4 VDD.t303 pfet_03v3 ad=2.6p pd=10.52u as=4.4p ps=20.88u w=10u l=0.28u
X420 XFE_O.NTAIL.t32 O_SENSE_BOOST.t12 VSS.t332 VSS.t331 nfet_03v3 ad=2.6p pd=10.52u as=2.6p ps=10.52u w=10u l=0.28u
X421 VSS.t176 XFE_E.DP.t13 XFE_E.H.t9 VSS.t175 nfet_03v3 ad=2.08p pd=8.52u as=3.52p ps=16.88u w=8u l=0.28u
X422 VDD.t273 XFE_O.HB.t22 FE_O_N.t4 VDD.t272 pfet_03v3 ad=3.52p pd=16.88u as=2.08p ps=8.52u w=8u l=0.28u
X423 VDD.t19 XFE_E.HB.t23 XFE_E.H.t0 VDD.t18 pfet_03v3 ad=2.08p pd=8.52u as=2.08p ps=8.52u w=8u l=0.28u
X424 VDD.t191 XFE_O.XP.t49 XFE_O.DP.t1 VDD.t190 pfet_03v3 ad=2.08p pd=8.52u as=3.52p ps=16.88u w=8u l=0.28u
X425 a_n6400_n14452.t2 a_n10800_n14372.t2 a_n7300_n14500.t1 VSS.t211 nfet_03v3 ad=2.6p pd=10.52u as=4.4p ps=20.88u w=10u l=0.28u
X426 XFE_O.NTAIL.t9 O_SENSE_CLK.t3 VSS.t221 VSS.t220 nfet_03v3 ad=2.6p pd=10.52u as=2.6p ps=10.52u w=10u l=0.28u
X427 VSS.t137 E_SENSE_BOOST.t17 XFE_E.NTAIL.t14 VSS.t36 nfet_03v3 ad=2.6p pd=10.52u as=2.6p ps=10.52u w=10u l=0.28u
X428 XFE_O.H.t4 XFE_O.DP.t10 VSS.t232 VSS.t231 nfet_03v3 ad=2.08p pd=8.52u as=2.08p ps=8.52u w=8u l=0.28u
X429 XFE_E.NIP.t9 RX_RAWN.t16 XFE_E.NTAIL.t6 VSS.t82 nfet_03v3 ad=2.08p pd=8.52u as=2.08p ps=8.52u w=8u l=0.28u
X430 XFE_E.XN.t5 XFE_E.XP.t42 XFE_E.NIN.t5 VSS.t63 nfet_03v3 ad=2.08p pd=8.52u as=2.08p ps=8.52u w=8u l=0.28u
X431 VDD.t185 a_484_3500.t1 VSS.t257 ppolyf_u r_width=1u r_length=1.4u
X432 VDD.t145 O_SENSE_CLK.t12 XFE_O.XN.t2 VDD.t144 pfet_03v3 ad=2.08p pd=8.52u as=2.08p ps=8.52u w=8u l=0.28u
R0 TERM_EN0_N.n0 TERM_EN0_N.t1 139.688
R1 TERM_EN0_N.n0 TERM_EN0_N.t0 139.688
R2 TERM_EN0_N.n2 TERM_EN0_N.t3 62.9541
R3 TERM_EN0_N.n1 TERM_EN0_N.t2 49.9184
R4 TERM_EN0_N.n1 TERM_EN0_N.n0 22.445
R5 TERM_EN0_N.n2 TERM_EN0_N.n1 0.8735
R6 TERM_EN0_N TERM_EN0_N.n2 0.539857
R7 TERM_EN1_N.n0 TERM_EN1_N.t1 139.688
R8 TERM_EN1_N.n0 TERM_EN1_N.t0 139.688
R9 TERM_EN1_N.n2 TERM_EN1_N.t3 62.9541
R10 TERM_EN1_N.n1 TERM_EN1_N.t2 49.9184
R11 TERM_EN1_N.n1 TERM_EN1_N.n0 22.445
R12 TERM_EN1_N.n2 TERM_EN1_N.n1 0.8735
R13 TERM_EN1_N TERM_EN1_N.n2 0.539857
R14 TERM_EN2_N.n0 TERM_EN2_N.t1 139.688
R15 TERM_EN2_N.n0 TERM_EN2_N.t0 139.688
R16 TERM_EN2_N.n2 TERM_EN2_N.t3 62.9541
R17 TERM_EN2_N.n1 TERM_EN2_N.t2 49.9184
R18 TERM_EN2_N.n1 TERM_EN2_N.n0 22.445
R19 TERM_EN2_N.n2 TERM_EN2_N.n1 0.8735
R20 TERM_EN2_N TERM_EN2_N.n2 0.539857
R21 TERM_EN3_N.n0 TERM_EN3_N.t1 139.688
R22 TERM_EN3_N.n0 TERM_EN3_N.t0 139.688
R23 TERM_EN3_N.n2 TERM_EN3_N.t3 62.9541
R24 TERM_EN3_N.n1 TERM_EN3_N.t2 49.9184
R25 TERM_EN3_N.n1 TERM_EN3_N.n0 22.445
R26 TERM_EN3_N.n2 TERM_EN3_N.n1 0.8735
R27 TERM_EN3_N TERM_EN3_N.n2 0.539857
R28 TERM_EN4_N.n0 TERM_EN4_N.t1 139.688
R29 TERM_EN4_N.n0 TERM_EN4_N.t0 139.688
R30 TERM_EN4_N.n2 TERM_EN4_N.t3 62.9541
R31 TERM_EN4_N.n1 TERM_EN4_N.t2 49.9184
R32 TERM_EN4_N.n1 TERM_EN4_N.n0 22.445
R33 TERM_EN4_N.n2 TERM_EN4_N.n1 0.8735
R34 TERM_EN4_N TERM_EN4_N.n2 0.539857
R35 TERM_EN5_N.n0 TERM_EN5_N.t1 139.688
R36 TERM_EN5_N.n0 TERM_EN5_N.t0 139.688
R37 TERM_EN5_N.n2 TERM_EN5_N.t3 62.9541
R38 TERM_EN5_N.n1 TERM_EN5_N.t2 49.9184
R39 TERM_EN5_N.n1 TERM_EN5_N.n0 22.445
R40 TERM_EN5_N.n2 TERM_EN5_N.n1 0.8735
R41 TERM_EN5_N TERM_EN5_N.n2 0.539857
R42 TERM_EN6_N.n0 TERM_EN6_N.t1 139.688
R43 TERM_EN6_N.n0 TERM_EN6_N.t0 139.688
R44 TERM_EN6_N.n2 TERM_EN6_N.t3 62.9541
R45 TERM_EN6_N.n1 TERM_EN6_N.t2 49.9184
R46 TERM_EN6_N.n1 TERM_EN6_N.n0 22.445
R47 TERM_EN6_N.n2 TERM_EN6_N.n1 0.8735
R48 TERM_EN6_N TERM_EN6_N.n2 0.539857
R49 RXN.n0 RXN.t8 139.689
R50 RXN.n0 RXN.t9 139.689
R51 RXN.n1 RXN.n0 32.6024
R52 RXN.n2 RXN.t4 16.451
R53 RXN.n7 RXN.t5 15.7257
R54 RXN.n6 RXN.t2 15.7257
R55 RXN.n5 RXN.t3 15.7257
R56 RXN.n4 RXN.t7 15.7257
R57 RXN.n3 RXN.t0 15.7257
R58 RXN.n2 RXN.t1 15.641
R59 RXN.n1 RXN.t6 12.4583
R60 RXN.n3 RXN.n2 0.8105
R61 RXN.n4 RXN.n3 0.8105
R62 RXN.n5 RXN.n4 0.8105
R63 RXN.n6 RXN.n5 0.8105
R64 RXN.n7 RXN.n6 0.8105
R65 RXN RXN.n7 0.6305
R66 RXN RXN.n1 0.1805
R67 RXP.n0 RXP.t8 139.689
R68 RXP.n0 RXP.t9 139.689
R69 RXP.n1 RXP.n0 32.6024
R70 RXP.n2 RXP.t2 16.451
R71 RXP.n3 RXP.t0 15.7257
R72 RXP.n4 RXP.t4 15.7257
R73 RXP.n5 RXP.t1 15.7257
R74 RXP.n6 RXP.t6 15.7257
R75 RXP.n7 RXP.t3 15.7257
R76 RXP.n2 RXP.t7 15.641
R77 RXP.n1 RXP.t5 12.4583
R78 RXP.n3 RXP.n2 0.8105
R79 RXP.n4 RXP.n3 0.8105
R80 RXP.n5 RXP.n4 0.8105
R81 RXP.n6 RXP.n5 0.8105
R82 RXP.n7 RXP.n6 0.8105
R83 RXP RXP.n7 0.6305
R84 RXP RXP.n1 0.1805
R85 RX_BIAS.n4 RX_BIAS.t4 139.702
R86 RX_BIAS.n0 RX_BIAS.t0 139.702
R87 RX_BIAS.n15 RX_BIAS.t9 139.702
R88 RX_BIAS.n11 RX_BIAS.t5 139.702
R89 RX_BIAS.n1 RX_BIAS.t1 135.246
R90 RX_BIAS.n2 RX_BIAS.t2 135.246
R91 RX_BIAS.n3 RX_BIAS.t3 135.246
R92 RX_BIAS.n12 RX_BIAS.t6 135.246
R93 RX_BIAS.n13 RX_BIAS.t7 135.246
R94 RX_BIAS.n14 RX_BIAS.t8 135.246
R95 RX_BIAS.n6 RX_BIAS.t10 35.4171
R96 RX_BIAS.n9 RX_BIAS.t13 35.4171
R97 RX_BIAS.n7 RX_BIAS.t11 30.9603
R98 RX_BIAS.n8 RX_BIAS.t12 30.9603
R99 RX_BIAS.n17 RX_BIAS.n10 21.4384
R100 RX_BIAS.n18 RX_BIAS.n5 18.9479
R101 RX_BIAS.n5 RX_BIAS.n2 18.4942
R102 RX_BIAS.n16 RX_BIAS.n13 18.4942
R103 RX_BIAS.n17 RX_BIAS.n16 18.0005
R104 RX_BIAS.n8 RX_BIAS.n7 11.6805
R105 RX_BIAS.n2 RX_BIAS.n1 11.6805
R106 RX_BIAS.n3 RX_BIAS.n2 11.6805
R107 RX_BIAS.n13 RX_BIAS.n12 11.6805
R108 RX_BIAS.n14 RX_BIAS.n13 11.6805
R109 RX_BIAS RX_BIAS.n18 7.56892
R110 RX_BIAS.n5 RX_BIAS.n0 7.16487
R111 RX_BIAS.n5 RX_BIAS.n4 7.16487
R112 RX_BIAS.n16 RX_BIAS.n11 7.16487
R113 RX_BIAS.n16 RX_BIAS.n15 7.16487
R114 RX_BIAS.n10 RX_BIAS.n6 7.09873
R115 RX_BIAS.n10 RX_BIAS.n9 7.09873
R116 RX_BIAS.n7 RX_BIAS.n6 4.42851
R117 RX_BIAS.n9 RX_BIAS.n8 4.42851
R118 RX_BIAS.n1 RX_BIAS.n0 4.42851
R119 RX_BIAS.n4 RX_BIAS.n3 4.42851
R120 RX_BIAS.n12 RX_BIAS.n11 4.42851
R121 RX_BIAS.n15 RX_BIAS.n14 4.42851
R122 RX_BIAS.n18 RX_BIAS.n17 0.947868
R123 VTHN.n0 VTHN.t0 35.4171
R124 VTHN.n0 VTHN.t1 35.3883
R125 VTHN VTHN.n0 26.2142
R126 VTHP.n0 VTHP.t1 35.4171
R127 VTHP.n0 VTHP.t0 35.3883
R128 VTHP VTHP.n0 26.2142
R129 RX_BW_EN_N.n1 RX_BW_EN_N.t3 104.718
R130 RX_BW_EN_N.n0 RX_BW_EN_N.t0 104.718
R131 RX_BW_EN_N.n1 RX_BW_EN_N.t2 102.35
R132 RX_BW_EN_N.n0 RX_BW_EN_N.t1 102.35
R133 RX_BW_EN_N RX_BW_EN_N.n0 1.06629
R134 RX_BW_EN_N RX_BW_EN_N.n1 0.829447
R135 O_SENSE_BOOST.t23 O_SENSE_BOOST.n52 153.859
R136 O_SENSE_BOOST.t0 O_SENSE_BOOST.n23 153.859
R137 O_SENSE_BOOST.t13 O_SENSE_BOOST.n38 153.739
R138 O_SENSE_BOOST.t15 O_SENSE_BOOST.n62 153.739
R139 O_SENSE_BOOST.n61 O_SENSE_BOOST.t16 153.739
R140 O_SENSE_BOOST.n52 O_SENSE_BOOST.t22 153.739
R141 O_SENSE_BOOST.n51 O_SENSE_BOOST.t21 153.739
R142 O_SENSE_BOOST.n50 O_SENSE_BOOST.t20 153.739
R143 O_SENSE_BOOST.n49 O_SENSE_BOOST.t19 153.739
R144 O_SENSE_BOOST.t18 O_SENSE_BOOST.n43 153.739
R145 O_SENSE_BOOST.n60 O_SENSE_BOOST.t17 153.739
R146 O_SENSE_BOOST.t14 O_SENSE_BOOST.n0 153.739
R147 O_SENSE_BOOST.n23 O_SENSE_BOOST.t1 153.739
R148 O_SENSE_BOOST.n22 O_SENSE_BOOST.t2 153.739
R149 O_SENSE_BOOST.n21 O_SENSE_BOOST.t3 153.739
R150 O_SENSE_BOOST.n20 O_SENSE_BOOST.t4 153.739
R151 O_SENSE_BOOST.n19 O_SENSE_BOOST.t5 153.739
R152 O_SENSE_BOOST.n18 O_SENSE_BOOST.t6 153.739
R153 O_SENSE_BOOST.n17 O_SENSE_BOOST.t7 153.739
R154 O_SENSE_BOOST.n16 O_SENSE_BOOST.t8 153.739
R155 O_SENSE_BOOST.n15 O_SENSE_BOOST.t9 153.739
R156 O_SENSE_BOOST.t10 O_SENSE_BOOST.n3 153.739
R157 O_SENSE_BOOST.n36 O_SENSE_BOOST.t11 153.739
R158 O_SENSE_BOOST.n37 O_SENSE_BOOST.t12 153.739
R159 O_SENSE_BOOST.n53 O_SENSE_BOOST.t23 139.702
R160 O_SENSE_BOOST.n24 O_SENSE_BOOST.t0 139.702
R161 O_SENSE_BOOST.n39 O_SENSE_BOOST.t13 135.246
R162 O_SENSE_BOOST.n63 O_SENSE_BOOST.t15 135.246
R163 O_SENSE_BOOST.t16 O_SENSE_BOOST.n42 135.246
R164 O_SENSE_BOOST.n54 O_SENSE_BOOST.t22 135.246
R165 O_SENSE_BOOST.n55 O_SENSE_BOOST.t21 135.246
R166 O_SENSE_BOOST.n56 O_SENSE_BOOST.t20 135.246
R167 O_SENSE_BOOST.n57 O_SENSE_BOOST.t19 135.246
R168 O_SENSE_BOOST.n58 O_SENSE_BOOST.t18 135.246
R169 O_SENSE_BOOST.t17 O_SENSE_BOOST.n59 135.246
R170 O_SENSE_BOOST.n40 O_SENSE_BOOST.t14 135.246
R171 O_SENSE_BOOST.n25 O_SENSE_BOOST.t1 135.246
R172 O_SENSE_BOOST.n26 O_SENSE_BOOST.t2 135.246
R173 O_SENSE_BOOST.n27 O_SENSE_BOOST.t3 135.246
R174 O_SENSE_BOOST.n28 O_SENSE_BOOST.t4 135.246
R175 O_SENSE_BOOST.n29 O_SENSE_BOOST.t5 135.246
R176 O_SENSE_BOOST.n30 O_SENSE_BOOST.t6 135.246
R177 O_SENSE_BOOST.n31 O_SENSE_BOOST.t7 135.246
R178 O_SENSE_BOOST.n32 O_SENSE_BOOST.t8 135.246
R179 O_SENSE_BOOST.n33 O_SENSE_BOOST.t9 135.246
R180 O_SENSE_BOOST.n34 O_SENSE_BOOST.t10 135.246
R181 O_SENSE_BOOST.t11 O_SENSE_BOOST.n35 135.246
R182 O_SENSE_BOOST.t12 O_SENSE_BOOST.n2 135.246
R183 O_SENSE_BOOST O_SENSE_BOOST.n66 31.5205
R184 O_SENSE_BOOST.n39 O_SENSE_BOOST.n1 18.4942
R185 O_SENSE_BOOST.n64 O_SENSE_BOOST.n63 18.4942
R186 O_SENSE_BOOST.n42 O_SENSE_BOOST.n41 18.4942
R187 O_SENSE_BOOST.n55 O_SENSE_BOOST.n48 18.4942
R188 O_SENSE_BOOST.n56 O_SENSE_BOOST.n47 18.4942
R189 O_SENSE_BOOST.n57 O_SENSE_BOOST.n46 18.4942
R190 O_SENSE_BOOST.n58 O_SENSE_BOOST.n45 18.4942
R191 O_SENSE_BOOST.n59 O_SENSE_BOOST.n44 18.4942
R192 O_SENSE_BOOST.n65 O_SENSE_BOOST.n40 18.4942
R193 O_SENSE_BOOST.n26 O_SENSE_BOOST.n14 18.4942
R194 O_SENSE_BOOST.n27 O_SENSE_BOOST.n13 18.4942
R195 O_SENSE_BOOST.n28 O_SENSE_BOOST.n12 18.4942
R196 O_SENSE_BOOST.n29 O_SENSE_BOOST.n11 18.4942
R197 O_SENSE_BOOST.n30 O_SENSE_BOOST.n10 18.4942
R198 O_SENSE_BOOST.n31 O_SENSE_BOOST.n9 18.4942
R199 O_SENSE_BOOST.n32 O_SENSE_BOOST.n8 18.4942
R200 O_SENSE_BOOST.n33 O_SENSE_BOOST.n7 18.4942
R201 O_SENSE_BOOST.n34 O_SENSE_BOOST.n6 18.4942
R202 O_SENSE_BOOST.n35 O_SENSE_BOOST.n5 18.4942
R203 O_SENSE_BOOST.n4 O_SENSE_BOOST.n2 18.4942
R204 O_SENSE_BOOST.n63 O_SENSE_BOOST.n40 11.6805
R205 O_SENSE_BOOST.n63 O_SENSE_BOOST.n42 11.6805
R206 O_SENSE_BOOST.n55 O_SENSE_BOOST.n54 11.6805
R207 O_SENSE_BOOST.n56 O_SENSE_BOOST.n55 11.6805
R208 O_SENSE_BOOST.n57 O_SENSE_BOOST.n56 11.6805
R209 O_SENSE_BOOST.n58 O_SENSE_BOOST.n57 11.6805
R210 O_SENSE_BOOST.n59 O_SENSE_BOOST.n58 11.6805
R211 O_SENSE_BOOST.n59 O_SENSE_BOOST.n42 11.6805
R212 O_SENSE_BOOST.n40 O_SENSE_BOOST.n39 11.6805
R213 O_SENSE_BOOST.n26 O_SENSE_BOOST.n25 11.6805
R214 O_SENSE_BOOST.n27 O_SENSE_BOOST.n26 11.6805
R215 O_SENSE_BOOST.n28 O_SENSE_BOOST.n27 11.6805
R216 O_SENSE_BOOST.n29 O_SENSE_BOOST.n28 11.6805
R217 O_SENSE_BOOST.n30 O_SENSE_BOOST.n29 11.6805
R218 O_SENSE_BOOST.n31 O_SENSE_BOOST.n30 11.6805
R219 O_SENSE_BOOST.n32 O_SENSE_BOOST.n31 11.6805
R220 O_SENSE_BOOST.n33 O_SENSE_BOOST.n32 11.6805
R221 O_SENSE_BOOST.n34 O_SENSE_BOOST.n33 11.6805
R222 O_SENSE_BOOST.n35 O_SENSE_BOOST.n34 11.6805
R223 O_SENSE_BOOST.n35 O_SENSE_BOOST.n2 11.6805
R224 O_SENSE_BOOST.n39 O_SENSE_BOOST.n2 11.6805
R225 O_SENSE_BOOST.n66 O_SENSE_BOOST.n65 10.3505
R226 O_SENSE_BOOST.n66 O_SENSE_BOOST.n0 9.88093
R227 O_SENSE_BOOST.n53 O_SENSE_BOOST.n48 7.17687
R228 O_SENSE_BOOST.n24 O_SENSE_BOOST.n14 7.17687
R229 O_SENSE_BOOST.n54 O_SENSE_BOOST.n53 4.42851
R230 O_SENSE_BOOST.n25 O_SENSE_BOOST.n24 4.42851
R231 O_SENSE_BOOST.n4 O_SENSE_BOOST.n1 0.1205
R232 O_SENSE_BOOST.n5 O_SENSE_BOOST.n4 0.1205
R233 O_SENSE_BOOST.n6 O_SENSE_BOOST.n5 0.1205
R234 O_SENSE_BOOST.n7 O_SENSE_BOOST.n6 0.1205
R235 O_SENSE_BOOST.n8 O_SENSE_BOOST.n7 0.1205
R236 O_SENSE_BOOST.n9 O_SENSE_BOOST.n8 0.1205
R237 O_SENSE_BOOST.n10 O_SENSE_BOOST.n9 0.1205
R238 O_SENSE_BOOST.n11 O_SENSE_BOOST.n10 0.1205
R239 O_SENSE_BOOST.n12 O_SENSE_BOOST.n11 0.1205
R240 O_SENSE_BOOST.n13 O_SENSE_BOOST.n12 0.1205
R241 O_SENSE_BOOST.n14 O_SENSE_BOOST.n13 0.1205
R242 O_SENSE_BOOST.n38 O_SENSE_BOOST.n37 0.1205
R243 O_SENSE_BOOST.n37 O_SENSE_BOOST.n36 0.1205
R244 O_SENSE_BOOST.n36 O_SENSE_BOOST.n3 0.1205
R245 O_SENSE_BOOST.n15 O_SENSE_BOOST.n3 0.1205
R246 O_SENSE_BOOST.n16 O_SENSE_BOOST.n15 0.1205
R247 O_SENSE_BOOST.n17 O_SENSE_BOOST.n16 0.1205
R248 O_SENSE_BOOST.n18 O_SENSE_BOOST.n17 0.1205
R249 O_SENSE_BOOST.n19 O_SENSE_BOOST.n18 0.1205
R250 O_SENSE_BOOST.n20 O_SENSE_BOOST.n19 0.1205
R251 O_SENSE_BOOST.n21 O_SENSE_BOOST.n20 0.1205
R252 O_SENSE_BOOST.n22 O_SENSE_BOOST.n21 0.1205
R253 O_SENSE_BOOST.n23 O_SENSE_BOOST.n22 0.1205
R254 O_SENSE_BOOST.n52 O_SENSE_BOOST.n51 0.1205
R255 O_SENSE_BOOST.n51 O_SENSE_BOOST.n50 0.1205
R256 O_SENSE_BOOST.n50 O_SENSE_BOOST.n49 0.1205
R257 O_SENSE_BOOST.n49 O_SENSE_BOOST.n43 0.1205
R258 O_SENSE_BOOST.n60 O_SENSE_BOOST.n43 0.1205
R259 O_SENSE_BOOST.n61 O_SENSE_BOOST.n60 0.1205
R260 O_SENSE_BOOST.n62 O_SENSE_BOOST.n61 0.1205
R261 O_SENSE_BOOST.n48 O_SENSE_BOOST.n47 0.1205
R262 O_SENSE_BOOST.n47 O_SENSE_BOOST.n46 0.1205
R263 O_SENSE_BOOST.n46 O_SENSE_BOOST.n45 0.1205
R264 O_SENSE_BOOST.n45 O_SENSE_BOOST.n44 0.1205
R265 O_SENSE_BOOST.n44 O_SENSE_BOOST.n41 0.1205
R266 O_SENSE_BOOST.n64 O_SENSE_BOOST.n41 0.1205
R267 O_SENSE_BOOST.n65 O_SENSE_BOOST.n1 0.1085
R268 O_SENSE_BOOST.n38 O_SENSE_BOOST.n0 0.1085
R269 O_SENSE_BOOST.n62 O_SENSE_BOOST.n0 0.1085
R270 O_SENSE_BOOST.n65 O_SENSE_BOOST.n64 0.1085
R271 E_SENSE_BOOST.t23 E_SENSE_BOOST.n47 153.859
R272 E_SENSE_BOOST.t0 E_SENSE_BOOST.n13 153.859
R273 E_SENSE_BOOST.t8 E_SENSE_BOOST.n23 153.739
R274 E_SENSE_BOOST.t10 E_SENSE_BOOST.n62 153.739
R275 E_SENSE_BOOST.n61 E_SENSE_BOOST.t11 153.739
R276 E_SENSE_BOOST.n47 E_SENSE_BOOST.t22 153.739
R277 E_SENSE_BOOST.n46 E_SENSE_BOOST.t21 153.739
R278 E_SENSE_BOOST.n45 E_SENSE_BOOST.t20 153.739
R279 E_SENSE_BOOST.n44 E_SENSE_BOOST.t19 153.739
R280 E_SENSE_BOOST.n43 E_SENSE_BOOST.t18 153.739
R281 E_SENSE_BOOST.n42 E_SENSE_BOOST.t17 153.739
R282 E_SENSE_BOOST.n41 E_SENSE_BOOST.t16 153.739
R283 E_SENSE_BOOST.n40 E_SENSE_BOOST.t15 153.739
R284 E_SENSE_BOOST.n39 E_SENSE_BOOST.t14 153.739
R285 E_SENSE_BOOST.t13 E_SENSE_BOOST.n28 153.739
R286 E_SENSE_BOOST.n60 E_SENSE_BOOST.t12 153.739
R287 E_SENSE_BOOST.t9 E_SENSE_BOOST.n0 153.739
R288 E_SENSE_BOOST.n13 E_SENSE_BOOST.t1 153.739
R289 E_SENSE_BOOST.n12 E_SENSE_BOOST.t2 153.739
R290 E_SENSE_BOOST.n11 E_SENSE_BOOST.t3 153.739
R291 E_SENSE_BOOST.n10 E_SENSE_BOOST.t4 153.739
R292 E_SENSE_BOOST.t5 E_SENSE_BOOST.n3 153.739
R293 E_SENSE_BOOST.n21 E_SENSE_BOOST.t6 153.739
R294 E_SENSE_BOOST.n22 E_SENSE_BOOST.t7 153.739
R295 E_SENSE_BOOST.n48 E_SENSE_BOOST.t23 139.702
R296 E_SENSE_BOOST.n14 E_SENSE_BOOST.t0 139.702
R297 E_SENSE_BOOST.n24 E_SENSE_BOOST.t8 135.246
R298 E_SENSE_BOOST.n63 E_SENSE_BOOST.t10 135.246
R299 E_SENSE_BOOST.t11 E_SENSE_BOOST.n27 135.246
R300 E_SENSE_BOOST.n49 E_SENSE_BOOST.t22 135.246
R301 E_SENSE_BOOST.n50 E_SENSE_BOOST.t21 135.246
R302 E_SENSE_BOOST.n51 E_SENSE_BOOST.t20 135.246
R303 E_SENSE_BOOST.n52 E_SENSE_BOOST.t19 135.246
R304 E_SENSE_BOOST.n53 E_SENSE_BOOST.t18 135.246
R305 E_SENSE_BOOST.n54 E_SENSE_BOOST.t17 135.246
R306 E_SENSE_BOOST.n55 E_SENSE_BOOST.t16 135.246
R307 E_SENSE_BOOST.n56 E_SENSE_BOOST.t15 135.246
R308 E_SENSE_BOOST.n57 E_SENSE_BOOST.t14 135.246
R309 E_SENSE_BOOST.n58 E_SENSE_BOOST.t13 135.246
R310 E_SENSE_BOOST.t12 E_SENSE_BOOST.n59 135.246
R311 E_SENSE_BOOST.n25 E_SENSE_BOOST.t9 135.246
R312 E_SENSE_BOOST.n15 E_SENSE_BOOST.t1 135.246
R313 E_SENSE_BOOST.n16 E_SENSE_BOOST.t2 135.246
R314 E_SENSE_BOOST.n17 E_SENSE_BOOST.t3 135.246
R315 E_SENSE_BOOST.n18 E_SENSE_BOOST.t4 135.246
R316 E_SENSE_BOOST.n19 E_SENSE_BOOST.t5 135.246
R317 E_SENSE_BOOST.t6 E_SENSE_BOOST.n20 135.246
R318 E_SENSE_BOOST.t7 E_SENSE_BOOST.n2 135.246
R319 E_SENSE_BOOST E_SENSE_BOOST.n66 31.5205
R320 E_SENSE_BOOST.n24 E_SENSE_BOOST.n1 18.4942
R321 E_SENSE_BOOST.n64 E_SENSE_BOOST.n63 18.4942
R322 E_SENSE_BOOST.n27 E_SENSE_BOOST.n26 18.4942
R323 E_SENSE_BOOST.n50 E_SENSE_BOOST.n38 18.4942
R324 E_SENSE_BOOST.n51 E_SENSE_BOOST.n37 18.4942
R325 E_SENSE_BOOST.n52 E_SENSE_BOOST.n36 18.4942
R326 E_SENSE_BOOST.n53 E_SENSE_BOOST.n35 18.4942
R327 E_SENSE_BOOST.n54 E_SENSE_BOOST.n34 18.4942
R328 E_SENSE_BOOST.n55 E_SENSE_BOOST.n33 18.4942
R329 E_SENSE_BOOST.n56 E_SENSE_BOOST.n32 18.4942
R330 E_SENSE_BOOST.n57 E_SENSE_BOOST.n31 18.4942
R331 E_SENSE_BOOST.n58 E_SENSE_BOOST.n30 18.4942
R332 E_SENSE_BOOST.n59 E_SENSE_BOOST.n29 18.4942
R333 E_SENSE_BOOST.n65 E_SENSE_BOOST.n25 18.4942
R334 E_SENSE_BOOST.n16 E_SENSE_BOOST.n9 18.4942
R335 E_SENSE_BOOST.n17 E_SENSE_BOOST.n8 18.4942
R336 E_SENSE_BOOST.n18 E_SENSE_BOOST.n7 18.4942
R337 E_SENSE_BOOST.n19 E_SENSE_BOOST.n6 18.4942
R338 E_SENSE_BOOST.n20 E_SENSE_BOOST.n5 18.4942
R339 E_SENSE_BOOST.n4 E_SENSE_BOOST.n2 18.4942
R340 E_SENSE_BOOST.n63 E_SENSE_BOOST.n25 11.6805
R341 E_SENSE_BOOST.n63 E_SENSE_BOOST.n27 11.6805
R342 E_SENSE_BOOST.n50 E_SENSE_BOOST.n49 11.6805
R343 E_SENSE_BOOST.n51 E_SENSE_BOOST.n50 11.6805
R344 E_SENSE_BOOST.n52 E_SENSE_BOOST.n51 11.6805
R345 E_SENSE_BOOST.n53 E_SENSE_BOOST.n52 11.6805
R346 E_SENSE_BOOST.n54 E_SENSE_BOOST.n53 11.6805
R347 E_SENSE_BOOST.n55 E_SENSE_BOOST.n54 11.6805
R348 E_SENSE_BOOST.n56 E_SENSE_BOOST.n55 11.6805
R349 E_SENSE_BOOST.n57 E_SENSE_BOOST.n56 11.6805
R350 E_SENSE_BOOST.n58 E_SENSE_BOOST.n57 11.6805
R351 E_SENSE_BOOST.n59 E_SENSE_BOOST.n58 11.6805
R352 E_SENSE_BOOST.n59 E_SENSE_BOOST.n27 11.6805
R353 E_SENSE_BOOST.n25 E_SENSE_BOOST.n24 11.6805
R354 E_SENSE_BOOST.n16 E_SENSE_BOOST.n15 11.6805
R355 E_SENSE_BOOST.n17 E_SENSE_BOOST.n16 11.6805
R356 E_SENSE_BOOST.n18 E_SENSE_BOOST.n17 11.6805
R357 E_SENSE_BOOST.n19 E_SENSE_BOOST.n18 11.6805
R358 E_SENSE_BOOST.n20 E_SENSE_BOOST.n19 11.6805
R359 E_SENSE_BOOST.n20 E_SENSE_BOOST.n2 11.6805
R360 E_SENSE_BOOST.n24 E_SENSE_BOOST.n2 11.6805
R361 E_SENSE_BOOST.n66 E_SENSE_BOOST.n65 10.3505
R362 E_SENSE_BOOST.n66 E_SENSE_BOOST.n0 9.88093
R363 E_SENSE_BOOST.n48 E_SENSE_BOOST.n38 7.17687
R364 E_SENSE_BOOST.n14 E_SENSE_BOOST.n9 7.17687
R365 E_SENSE_BOOST.n49 E_SENSE_BOOST.n48 4.42851
R366 E_SENSE_BOOST.n15 E_SENSE_BOOST.n14 4.42851
R367 E_SENSE_BOOST.n4 E_SENSE_BOOST.n1 0.1205
R368 E_SENSE_BOOST.n5 E_SENSE_BOOST.n4 0.1205
R369 E_SENSE_BOOST.n6 E_SENSE_BOOST.n5 0.1205
R370 E_SENSE_BOOST.n7 E_SENSE_BOOST.n6 0.1205
R371 E_SENSE_BOOST.n8 E_SENSE_BOOST.n7 0.1205
R372 E_SENSE_BOOST.n9 E_SENSE_BOOST.n8 0.1205
R373 E_SENSE_BOOST.n23 E_SENSE_BOOST.n22 0.1205
R374 E_SENSE_BOOST.n22 E_SENSE_BOOST.n21 0.1205
R375 E_SENSE_BOOST.n21 E_SENSE_BOOST.n3 0.1205
R376 E_SENSE_BOOST.n10 E_SENSE_BOOST.n3 0.1205
R377 E_SENSE_BOOST.n11 E_SENSE_BOOST.n10 0.1205
R378 E_SENSE_BOOST.n12 E_SENSE_BOOST.n11 0.1205
R379 E_SENSE_BOOST.n13 E_SENSE_BOOST.n12 0.1205
R380 E_SENSE_BOOST.n47 E_SENSE_BOOST.n46 0.1205
R381 E_SENSE_BOOST.n46 E_SENSE_BOOST.n45 0.1205
R382 E_SENSE_BOOST.n45 E_SENSE_BOOST.n44 0.1205
R383 E_SENSE_BOOST.n44 E_SENSE_BOOST.n43 0.1205
R384 E_SENSE_BOOST.n43 E_SENSE_BOOST.n42 0.1205
R385 E_SENSE_BOOST.n42 E_SENSE_BOOST.n41 0.1205
R386 E_SENSE_BOOST.n41 E_SENSE_BOOST.n40 0.1205
R387 E_SENSE_BOOST.n40 E_SENSE_BOOST.n39 0.1205
R388 E_SENSE_BOOST.n39 E_SENSE_BOOST.n28 0.1205
R389 E_SENSE_BOOST.n60 E_SENSE_BOOST.n28 0.1205
R390 E_SENSE_BOOST.n61 E_SENSE_BOOST.n60 0.1205
R391 E_SENSE_BOOST.n62 E_SENSE_BOOST.n61 0.1205
R392 E_SENSE_BOOST.n38 E_SENSE_BOOST.n37 0.1205
R393 E_SENSE_BOOST.n37 E_SENSE_BOOST.n36 0.1205
R394 E_SENSE_BOOST.n36 E_SENSE_BOOST.n35 0.1205
R395 E_SENSE_BOOST.n35 E_SENSE_BOOST.n34 0.1205
R396 E_SENSE_BOOST.n34 E_SENSE_BOOST.n33 0.1205
R397 E_SENSE_BOOST.n33 E_SENSE_BOOST.n32 0.1205
R398 E_SENSE_BOOST.n32 E_SENSE_BOOST.n31 0.1205
R399 E_SENSE_BOOST.n31 E_SENSE_BOOST.n30 0.1205
R400 E_SENSE_BOOST.n30 E_SENSE_BOOST.n29 0.1205
R401 E_SENSE_BOOST.n29 E_SENSE_BOOST.n26 0.1205
R402 E_SENSE_BOOST.n64 E_SENSE_BOOST.n26 0.1205
R403 E_SENSE_BOOST.n65 E_SENSE_BOOST.n1 0.1085
R404 E_SENSE_BOOST.n23 E_SENSE_BOOST.n0 0.1085
R405 E_SENSE_BOOST.n62 E_SENSE_BOOST.n0 0.1085
R406 E_SENSE_BOOST.n65 E_SENSE_BOOST.n64 0.1085
R407 RX_RAWN.t4 RX_RAWN.n7 127.788
R408 RX_RAWN.t12 RX_RAWN.n27 127.788
R409 RX_RAWN.t11 RX_RAWN.n0 127.776
R410 RX_RAWN.t19 RX_RAWN.n20 127.776
R411 RX_RAWN.t9 RX_RAWN.n14 127.668
R412 RX_RAWN.t10 RX_RAWN.n0 127.668
R413 RX_RAWN.n7 RX_RAWN.t5 127.668
R414 RX_RAWN.t6 RX_RAWN.n3 127.668
R415 RX_RAWN.n12 RX_RAWN.t7 127.668
R416 RX_RAWN.n13 RX_RAWN.t8 127.668
R417 RX_RAWN.t17 RX_RAWN.n34 127.668
R418 RX_RAWN.t18 RX_RAWN.n20 127.668
R419 RX_RAWN.n27 RX_RAWN.t13 127.668
R420 RX_RAWN.t14 RX_RAWN.n23 127.668
R421 RX_RAWN.n32 RX_RAWN.t15 127.668
R422 RX_RAWN.n33 RX_RAWN.t16 127.668
R423 RX_RAWN.n8 RX_RAWN.t4 113.632
R424 RX_RAWN.n28 RX_RAWN.t12 113.632
R425 RX_RAWN.n17 RX_RAWN.t11 113.629
R426 RX_RAWN.n37 RX_RAWN.t19 113.629
R427 RX_RAWN.n15 RX_RAWN.t9 109.174
R428 RX_RAWN.n16 RX_RAWN.t10 109.174
R429 RX_RAWN.n9 RX_RAWN.t5 109.174
R430 RX_RAWN.n10 RX_RAWN.t6 109.174
R431 RX_RAWN.t7 RX_RAWN.n11 109.174
R432 RX_RAWN.t8 RX_RAWN.n2 109.174
R433 RX_RAWN.n35 RX_RAWN.t17 109.174
R434 RX_RAWN.n36 RX_RAWN.t18 109.174
R435 RX_RAWN.n29 RX_RAWN.t13 109.174
R436 RX_RAWN.n30 RX_RAWN.t14 109.174
R437 RX_RAWN.t15 RX_RAWN.n31 109.174
R438 RX_RAWN.t16 RX_RAWN.n22 109.174
R439 RX_RAWN.n40 RX_RAWN.n19 48.1811
R440 RX_RAWN.n40 RX_RAWN.n39 45.4727
R441 RX_RAWN.n15 RX_RAWN.n1 18.4942
R442 RX_RAWN.n10 RX_RAWN.n6 18.4942
R443 RX_RAWN.n11 RX_RAWN.n5 18.4942
R444 RX_RAWN.n4 RX_RAWN.n2 18.4942
R445 RX_RAWN.n35 RX_RAWN.n21 18.4942
R446 RX_RAWN.n30 RX_RAWN.n26 18.4942
R447 RX_RAWN.n31 RX_RAWN.n25 18.4942
R448 RX_RAWN.n24 RX_RAWN.n22 18.4942
R449 RX_RAWN.n43 RX_RAWN.t2 12.3293
R450 RX_RAWN.n16 RX_RAWN.n15 11.6805
R451 RX_RAWN.n10 RX_RAWN.n9 11.6805
R452 RX_RAWN.n11 RX_RAWN.n10 11.6805
R453 RX_RAWN.n11 RX_RAWN.n2 11.6805
R454 RX_RAWN.n15 RX_RAWN.n2 11.6805
R455 RX_RAWN.n36 RX_RAWN.n35 11.6805
R456 RX_RAWN.n30 RX_RAWN.n29 11.6805
R457 RX_RAWN.n31 RX_RAWN.n30 11.6805
R458 RX_RAWN.n31 RX_RAWN.n22 11.6805
R459 RX_RAWN.n35 RX_RAWN.n22 11.6805
R460 RX_RAWN.n19 RX_RAWN.n0 10.8396
R461 RX_RAWN.n39 RX_RAWN.n20 10.8396
R462 RX_RAWN.n42 RX_RAWN.t0 10.6142
R463 RX_RAWN.n19 RX_RAWN.n18 9.0005
R464 RX_RAWN.n39 RX_RAWN.n38 9.0005
R465 RX_RAWN.n8 RX_RAWN.n6 7.17687
R466 RX_RAWN.n28 RX_RAWN.n26 7.17687
R467 RX_RAWN.n18 RX_RAWN.n17 7.05405
R468 RX_RAWN.n38 RX_RAWN.n37 7.05405
R469 RX_RAWN.n41 RX_RAWN.t3 6.0676
R470 RX_RAWN.n41 RX_RAWN.t1 6.06436
R471 RX_RAWN.n17 RX_RAWN.n16 4.4296
R472 RX_RAWN.n37 RX_RAWN.n36 4.4296
R473 RX_RAWN.n9 RX_RAWN.n8 4.42851
R474 RX_RAWN.n29 RX_RAWN.n28 4.42851
R475 RX_RAWN.n42 RX_RAWN.n41 3.78254
R476 RX_RAWN RX_RAWN.n40 2.56076
R477 RX_RAWN RX_RAWN.n43 1.52901
R478 RX_RAWN.n43 RX_RAWN.n42 0.733182
R479 RX_RAWN.n4 RX_RAWN.n1 0.1205
R480 RX_RAWN.n5 RX_RAWN.n4 0.1205
R481 RX_RAWN.n6 RX_RAWN.n5 0.1205
R482 RX_RAWN.n14 RX_RAWN.n13 0.1205
R483 RX_RAWN.n13 RX_RAWN.n12 0.1205
R484 RX_RAWN.n12 RX_RAWN.n3 0.1205
R485 RX_RAWN.n7 RX_RAWN.n3 0.1205
R486 RX_RAWN.n24 RX_RAWN.n21 0.1205
R487 RX_RAWN.n25 RX_RAWN.n24 0.1205
R488 RX_RAWN.n26 RX_RAWN.n25 0.1205
R489 RX_RAWN.n34 RX_RAWN.n33 0.1205
R490 RX_RAWN.n33 RX_RAWN.n32 0.1205
R491 RX_RAWN.n32 RX_RAWN.n23 0.1205
R492 RX_RAWN.n27 RX_RAWN.n23 0.1205
R493 RX_RAWN.n18 RX_RAWN.n1 0.1085
R494 RX_RAWN.n14 RX_RAWN.n0 0.1085
R495 RX_RAWN.n38 RX_RAWN.n21 0.1085
R496 RX_RAWN.n34 RX_RAWN.n20 0.1085
R497 RX_RAWP.t19 RX_RAWP.n28 127.788
R498 RX_RAWP.t11 RX_RAWP.n10 127.788
R499 RX_RAWP.t12 RX_RAWP.n20 127.776
R500 RX_RAWP.t4 RX_RAWP.n0 127.776
R501 RX_RAWP.t14 RX_RAWP.n35 127.668
R502 RX_RAWP.n34 RX_RAWP.t15 127.668
R503 RX_RAWP.n28 RX_RAWP.t18 127.668
R504 RX_RAWP.t17 RX_RAWP.n25 127.668
R505 RX_RAWP.n33 RX_RAWP.t16 127.668
R506 RX_RAWP.t13 RX_RAWP.n20 127.668
R507 RX_RAWP.n10 RX_RAWP.t10 127.668
R508 RX_RAWP.n9 RX_RAWP.t9 127.668
R509 RX_RAWP.n8 RX_RAWP.t8 127.668
R510 RX_RAWP.n7 RX_RAWP.t7 127.668
R511 RX_RAWP.n6 RX_RAWP.t6 127.668
R512 RX_RAWP.t5 RX_RAWP.n0 127.668
R513 RX_RAWP.n29 RX_RAWP.t19 113.632
R514 RX_RAWP.n11 RX_RAWP.t11 113.632
R515 RX_RAWP.n21 RX_RAWP.t12 113.629
R516 RX_RAWP.n1 RX_RAWP.t4 113.629
R517 RX_RAWP.n36 RX_RAWP.t14 109.174
R518 RX_RAWP.t15 RX_RAWP.n23 109.174
R519 RX_RAWP.n30 RX_RAWP.t18 109.174
R520 RX_RAWP.n31 RX_RAWP.t17 109.174
R521 RX_RAWP.t16 RX_RAWP.n32 109.174
R522 RX_RAWP.n24 RX_RAWP.t13 109.174
R523 RX_RAWP.t10 RX_RAWP.n5 109.174
R524 RX_RAWP.n13 RX_RAWP.t9 109.174
R525 RX_RAWP.n14 RX_RAWP.t8 109.174
R526 RX_RAWP.n15 RX_RAWP.t7 109.174
R527 RX_RAWP.n16 RX_RAWP.t6 109.174
R528 RX_RAWP.n3 RX_RAWP.t5 109.174
R529 RX_RAWP.n40 RX_RAWP.n39 43.7808
R530 RX_RAWP.n40 RX_RAWP.n19 42.2566
R531 RX_RAWP.n37 RX_RAWP.n36 18.4942
R532 RX_RAWP.n23 RX_RAWP.n22 18.4942
R533 RX_RAWP.n31 RX_RAWP.n27 18.4942
R534 RX_RAWP.n32 RX_RAWP.n26 18.4942
R535 RX_RAWP.n13 RX_RAWP.n12 18.4942
R536 RX_RAWP.n14 RX_RAWP.n4 18.4942
R537 RX_RAWP.n15 RX_RAWP.n2 18.4942
R538 RX_RAWP.n17 RX_RAWP.n16 18.4942
R539 RX_RAWP.n43 RX_RAWP.t2 12.5711
R540 RX_RAWP.n36 RX_RAWP.n24 11.6805
R541 RX_RAWP.n36 RX_RAWP.n23 11.6805
R542 RX_RAWP.n31 RX_RAWP.n30 11.6805
R543 RX_RAWP.n32 RX_RAWP.n31 11.6805
R544 RX_RAWP.n32 RX_RAWP.n23 11.6805
R545 RX_RAWP.n14 RX_RAWP.n13 11.6805
R546 RX_RAWP.n13 RX_RAWP.n5 11.6805
R547 RX_RAWP.n15 RX_RAWP.n14 11.6805
R548 RX_RAWP.n16 RX_RAWP.n15 11.6805
R549 RX_RAWP.n16 RX_RAWP.n3 11.6805
R550 RX_RAWP.n39 RX_RAWP.n20 10.8396
R551 RX_RAWP.n19 RX_RAWP.n0 10.8396
R552 RX_RAWP.n42 RX_RAWP.t0 10.6142
R553 RX_RAWP.n39 RX_RAWP.n38 9.0005
R554 RX_RAWP.n19 RX_RAWP.n18 9.0005
R555 RX_RAWP.n29 RX_RAWP.n27 7.17687
R556 RX_RAWP.n12 RX_RAWP.n11 7.17687
R557 RX_RAWP.n38 RX_RAWP.n21 7.05405
R558 RX_RAWP.n18 RX_RAWP.n1 7.05405
R559 RX_RAWP RX_RAWP.n43 6.39524
R560 RX_RAWP.n41 RX_RAWP.t3 6.0676
R561 RX_RAWP.n41 RX_RAWP.t1 6.06436
R562 RX_RAWP.n24 RX_RAWP.n21 4.4296
R563 RX_RAWP.n3 RX_RAWP.n1 4.4296
R564 RX_RAWP.n30 RX_RAWP.n29 4.42851
R565 RX_RAWP.n11 RX_RAWP.n5 4.42851
R566 RX_RAWP.n42 RX_RAWP.n41 3.78254
R567 RX_RAWP RX_RAWP.n40 1.37655
R568 RX_RAWP.n43 RX_RAWP.n42 0.491409
R569 RX_RAWP.n28 RX_RAWP.n25 0.1205
R570 RX_RAWP.n33 RX_RAWP.n25 0.1205
R571 RX_RAWP.n34 RX_RAWP.n33 0.1205
R572 RX_RAWP.n35 RX_RAWP.n34 0.1205
R573 RX_RAWP.n27 RX_RAWP.n26 0.1205
R574 RX_RAWP.n26 RX_RAWP.n22 0.1205
R575 RX_RAWP.n37 RX_RAWP.n22 0.1205
R576 RX_RAWP.n10 RX_RAWP.n9 0.1205
R577 RX_RAWP.n9 RX_RAWP.n8 0.1205
R578 RX_RAWP.n8 RX_RAWP.n7 0.1205
R579 RX_RAWP.n7 RX_RAWP.n6 0.1205
R580 RX_RAWP.n12 RX_RAWP.n4 0.1205
R581 RX_RAWP.n4 RX_RAWP.n2 0.1205
R582 RX_RAWP.n17 RX_RAWP.n2 0.1205
R583 RX_RAWP.n35 RX_RAWP.n20 0.1085
R584 RX_RAWP.n38 RX_RAWP.n37 0.1085
R585 RX_RAWP.n6 RX_RAWP.n0 0.1085
R586 RX_RAWP.n18 RX_RAWP.n17 0.1085
R587 FE_O_N.n5 FE_O_N.n2 10.957
R588 FE_O_N.n5 FE_O_N.n4 10.5657
R589 FE_O_N FE_O_N.n5 8.59007
R590 FE_O_N.n1 FE_O_N.t0 5.7796
R591 FE_O_N.n4 FE_O_N.t6 5.71396
R592 FE_O_N.n2 FE_O_N.t3 5.68486
R593 FE_O_N.n1 FE_O_N.n0 5.38537
R594 FE_O_N.n4 FE_O_N.n3 5.34435
R595 FE_O_N.n3 FE_O_N.t5 0.228
R596 FE_O_N.n3 FE_O_N.t4 0.228
R597 FE_O_N.n0 FE_O_N.t2 0.20525
R598 FE_O_N.n0 FE_O_N.t1 0.20525
R599 FE_O_N.n2 FE_O_N.n1 0.0952368
R600 FE_O_P.n5 FE_O_P.n1 11.0353
R601 FE_O_P.n5 FE_O_P.n4 10.4875
R602 FE_O_P FE_O_P.n5 8.47267
R603 FE_O_P.n3 FE_O_P.t0 5.7796
R604 FE_O_P.n1 FE_O_P.t6 5.71396
R605 FE_O_P.n4 FE_O_P.t3 5.68486
R606 FE_O_P.n3 FE_O_P.n2 5.38537
R607 FE_O_P.n1 FE_O_P.n0 5.34435
R608 FE_O_P.n0 FE_O_P.t5 0.228
R609 FE_O_P.n0 FE_O_P.t4 0.228
R610 FE_O_P.n2 FE_O_P.t2 0.20525
R611 FE_O_P.n2 FE_O_P.t1 0.20525
R612 FE_O_P.n4 FE_O_P.n3 0.0952368
R613 FE_E_N.n5 FE_E_N.n1 11.0353
R614 FE_E_N.n5 FE_E_N.n4 10.4875
R615 FE_E_N FE_E_N.n5 8.47267
R616 FE_E_N.n3 FE_E_N.t2 5.7796
R617 FE_E_N.n1 FE_E_N.t0 5.71396
R618 FE_E_N.n4 FE_E_N.t5 5.68486
R619 FE_E_N.n3 FE_E_N.n2 5.38537
R620 FE_E_N.n1 FE_E_N.n0 5.34435
R621 FE_E_N.n0 FE_E_N.t4 0.228
R622 FE_E_N.n0 FE_E_N.t3 0.228
R623 FE_E_N.n2 FE_E_N.t1 0.20525
R624 FE_E_N.n2 FE_E_N.t6 0.20525
R625 FE_E_N.n4 FE_E_N.n3 0.0952368
R626 FE_E_P.n5 FE_E_P.n2 10.957
R627 FE_E_P.n5 FE_E_P.n4 10.5657
R628 FE_E_P FE_E_P.n5 8.59007
R629 FE_E_P.n1 FE_E_P.t4 5.7796
R630 FE_E_P.n4 FE_E_P.t1 5.71396
R631 FE_E_P.n2 FE_E_P.t6 5.68486
R632 FE_E_P.n1 FE_E_P.n0 5.38537
R633 FE_E_P.n4 FE_E_P.n3 5.34435
R634 FE_E_P.n3 FE_E_P.t0 0.228
R635 FE_E_P.n3 FE_E_P.t5 0.228
R636 FE_E_P.n0 FE_E_P.t3 0.20525
R637 FE_E_P.n0 FE_E_P.t2 0.20525
R638 FE_E_P.n2 FE_E_P.n1 0.0952368
R639 O_SENSE_CLK.n58 O_SENSE_CLK.t0 139.702
R640 O_SENSE_CLK.n60 O_SENSE_CLK.t2 135.246
R641 O_SENSE_CLK.n61 O_SENSE_CLK.t3 135.246
R642 O_SENSE_CLK.n62 O_SENSE_CLK.t4 135.246
R643 O_SENSE_CLK.n57 O_SENSE_CLK.t1 135.246
R644 O_SENSE_CLK.t14 O_SENSE_CLK.n8 127.788
R645 O_SENSE_CLK.t26 O_SENSE_CLK.n45 127.788
R646 O_SENSE_CLK.t31 O_SENSE_CLK.n87 127.788
R647 O_SENSE_CLK.t19 O_SENSE_CLK.n35 127.776
R648 O_SENSE_CLK.t5 O_SENSE_CLK.n0 127.668
R649 O_SENSE_CLK.t6 O_SENSE_CLK.n23 127.668
R650 O_SENSE_CLK.n22 O_SENSE_CLK.t7 127.668
R651 O_SENSE_CLK.n21 O_SENSE_CLK.t8 127.668
R652 O_SENSE_CLK.t9 O_SENSE_CLK.n3 127.668
R653 O_SENSE_CLK.t10 O_SENSE_CLK.n15 127.668
R654 O_SENSE_CLK.n14 O_SENSE_CLK.t11 127.668
R655 O_SENSE_CLK.n13 O_SENSE_CLK.t12 127.668
R656 O_SENSE_CLK.t13 O_SENSE_CLK.n8 127.668
R657 O_SENSE_CLK.n45 O_SENSE_CLK.t25 127.668
R658 O_SENSE_CLK.n44 O_SENSE_CLK.t24 127.668
R659 O_SENSE_CLK.n43 O_SENSE_CLK.t23 127.668
R660 O_SENSE_CLK.n42 O_SENSE_CLK.t22 127.668
R661 O_SENSE_CLK.n41 O_SENSE_CLK.t21 127.668
R662 O_SENSE_CLK.t20 O_SENSE_CLK.n35 127.668
R663 O_SENSE_CLK.t40 O_SENSE_CLK.n72 127.668
R664 O_SENSE_CLK.n87 O_SENSE_CLK.t32 127.668
R665 O_SENSE_CLK.n86 O_SENSE_CLK.t33 127.668
R666 O_SENSE_CLK.n85 O_SENSE_CLK.t34 127.668
R667 O_SENSE_CLK.n84 O_SENSE_CLK.t35 127.668
R668 O_SENSE_CLK.n83 O_SENSE_CLK.t36 127.668
R669 O_SENSE_CLK.n82 O_SENSE_CLK.t37 127.668
R670 O_SENSE_CLK.n81 O_SENSE_CLK.t38 127.668
R671 O_SENSE_CLK.n80 O_SENSE_CLK.t39 127.668
R672 O_SENSE_CLK.n29 O_SENSE_CLK.t18 113.632
R673 O_SENSE_CLK.n10 O_SENSE_CLK.t14 113.632
R674 O_SENSE_CLK.n66 O_SENSE_CLK.t30 113.632
R675 O_SENSE_CLK.n46 O_SENSE_CLK.t26 113.632
R676 O_SENSE_CLK.n88 O_SENSE_CLK.t31 113.632
R677 O_SENSE_CLK.n36 O_SENSE_CLK.t19 113.629
R678 O_SENSE_CLK.n30 O_SENSE_CLK.t17 109.174
R679 O_SENSE_CLK.n31 O_SENSE_CLK.t16 109.174
R680 O_SENSE_CLK.n28 O_SENSE_CLK.t15 109.174
R681 O_SENSE_CLK.n25 O_SENSE_CLK.t5 109.174
R682 O_SENSE_CLK.n24 O_SENSE_CLK.t6 109.174
R683 O_SENSE_CLK.t7 O_SENSE_CLK.n2 109.174
R684 O_SENSE_CLK.t8 O_SENSE_CLK.n20 109.174
R685 O_SENSE_CLK.n4 O_SENSE_CLK.t9 109.174
R686 O_SENSE_CLK.n16 O_SENSE_CLK.t10 109.174
R687 O_SENSE_CLK.t11 O_SENSE_CLK.n7 109.174
R688 O_SENSE_CLK.t12 O_SENSE_CLK.n12 109.174
R689 O_SENSE_CLK.n9 O_SENSE_CLK.t13 109.174
R690 O_SENSE_CLK.n67 O_SENSE_CLK.t29 109.174
R691 O_SENSE_CLK.n68 O_SENSE_CLK.t28 109.174
R692 O_SENSE_CLK.n65 O_SENSE_CLK.t27 109.174
R693 O_SENSE_CLK.t25 O_SENSE_CLK.n40 109.174
R694 O_SENSE_CLK.n48 O_SENSE_CLK.t24 109.174
R695 O_SENSE_CLK.n49 O_SENSE_CLK.t23 109.174
R696 O_SENSE_CLK.n50 O_SENSE_CLK.t22 109.174
R697 O_SENSE_CLK.n51 O_SENSE_CLK.t21 109.174
R698 O_SENSE_CLK.n38 O_SENSE_CLK.t20 109.174
R699 O_SENSE_CLK.n97 O_SENSE_CLK.t40 109.174
R700 O_SENSE_CLK.n89 O_SENSE_CLK.t32 109.174
R701 O_SENSE_CLK.n90 O_SENSE_CLK.t33 109.174
R702 O_SENSE_CLK.n91 O_SENSE_CLK.t34 109.174
R703 O_SENSE_CLK.n92 O_SENSE_CLK.t35 109.174
R704 O_SENSE_CLK.n93 O_SENSE_CLK.t36 109.174
R705 O_SENSE_CLK.n94 O_SENSE_CLK.t37 109.174
R706 O_SENSE_CLK.n95 O_SENSE_CLK.t38 109.174
R707 O_SENSE_CLK.n96 O_SENSE_CLK.t39 109.174
R708 O_SENSE_CLK.n34 O_SENSE_CLK.n33 24.5548
R709 O_SENSE_CLK.n71 O_SENSE_CLK.n70 24.5548
R710 O_SENSE_CLK.n34 O_SENSE_CLK.n27 20.0548
R711 O_SENSE_CLK.n63 O_SENSE_CLK.n62 18.5723
R712 O_SENSE_CLK.n33 O_SENSE_CLK.n28 18.5179
R713 O_SENSE_CLK.n70 O_SENSE_CLK.n65 18.5179
R714 O_SENSE_CLK.n32 O_SENSE_CLK.n31 18.4942
R715 O_SENSE_CLK.n60 O_SENSE_CLK.n59 18.4942
R716 O_SENSE_CLK.n61 O_SENSE_CLK.n56 18.4942
R717 O_SENSE_CLK.n26 O_SENSE_CLK.n25 18.4942
R718 O_SENSE_CLK.n24 O_SENSE_CLK.n1 18.4942
R719 O_SENSE_CLK.n5 O_SENSE_CLK.n2 18.4942
R720 O_SENSE_CLK.n20 O_SENSE_CLK.n19 18.4942
R721 O_SENSE_CLK.n18 O_SENSE_CLK.n4 18.4942
R722 O_SENSE_CLK.n17 O_SENSE_CLK.n16 18.4942
R723 O_SENSE_CLK.n7 O_SENSE_CLK.n6 18.4942
R724 O_SENSE_CLK.n12 O_SENSE_CLK.n11 18.4942
R725 O_SENSE_CLK.n69 O_SENSE_CLK.n68 18.4942
R726 O_SENSE_CLK.n48 O_SENSE_CLK.n47 18.4942
R727 O_SENSE_CLK.n49 O_SENSE_CLK.n39 18.4942
R728 O_SENSE_CLK.n50 O_SENSE_CLK.n37 18.4942
R729 O_SENSE_CLK.n52 O_SENSE_CLK.n51 18.4942
R730 O_SENSE_CLK.n98 O_SENSE_CLK.n97 18.4942
R731 O_SENSE_CLK.n90 O_SENSE_CLK.n79 18.4942
R732 O_SENSE_CLK.n91 O_SENSE_CLK.n78 18.4942
R733 O_SENSE_CLK.n92 O_SENSE_CLK.n77 18.4942
R734 O_SENSE_CLK.n93 O_SENSE_CLK.n76 18.4942
R735 O_SENSE_CLK.n94 O_SENSE_CLK.n75 18.4942
R736 O_SENSE_CLK.n95 O_SENSE_CLK.n74 18.4942
R737 O_SENSE_CLK.n96 O_SENSE_CLK.n73 18.4942
R738 O_SENSE_CLK.n55 O_SENSE_CLK.n54 15.5548
R739 O_SENSE_CLK.n100 O_SENSE_CLK.n99 15.5548
R740 O_SENSE_CLK.n64 O_SENSE_CLK.n63 14.5766
R741 O_SENSE_CLK O_SENSE_CLK.n100 13.9118
R742 O_SENSE_CLK.n31 O_SENSE_CLK.n30 11.6805
R743 O_SENSE_CLK.n31 O_SENSE_CLK.n28 11.6805
R744 O_SENSE_CLK.n60 O_SENSE_CLK.n57 11.6805
R745 O_SENSE_CLK.n61 O_SENSE_CLK.n60 11.6805
R746 O_SENSE_CLK.n62 O_SENSE_CLK.n61 11.6805
R747 O_SENSE_CLK.n25 O_SENSE_CLK.n24 11.6805
R748 O_SENSE_CLK.n24 O_SENSE_CLK.n2 11.6805
R749 O_SENSE_CLK.n20 O_SENSE_CLK.n2 11.6805
R750 O_SENSE_CLK.n20 O_SENSE_CLK.n4 11.6805
R751 O_SENSE_CLK.n16 O_SENSE_CLK.n4 11.6805
R752 O_SENSE_CLK.n16 O_SENSE_CLK.n7 11.6805
R753 O_SENSE_CLK.n12 O_SENSE_CLK.n7 11.6805
R754 O_SENSE_CLK.n12 O_SENSE_CLK.n9 11.6805
R755 O_SENSE_CLK.n68 O_SENSE_CLK.n67 11.6805
R756 O_SENSE_CLK.n68 O_SENSE_CLK.n65 11.6805
R757 O_SENSE_CLK.n49 O_SENSE_CLK.n48 11.6805
R758 O_SENSE_CLK.n48 O_SENSE_CLK.n40 11.6805
R759 O_SENSE_CLK.n50 O_SENSE_CLK.n49 11.6805
R760 O_SENSE_CLK.n51 O_SENSE_CLK.n50 11.6805
R761 O_SENSE_CLK.n51 O_SENSE_CLK.n38 11.6805
R762 O_SENSE_CLK.n90 O_SENSE_CLK.n89 11.6805
R763 O_SENSE_CLK.n91 O_SENSE_CLK.n90 11.6805
R764 O_SENSE_CLK.n92 O_SENSE_CLK.n91 11.6805
R765 O_SENSE_CLK.n93 O_SENSE_CLK.n92 11.6805
R766 O_SENSE_CLK.n94 O_SENSE_CLK.n93 11.6805
R767 O_SENSE_CLK.n95 O_SENSE_CLK.n94 11.6805
R768 O_SENSE_CLK.n96 O_SENSE_CLK.n95 11.6805
R769 O_SENSE_CLK.n97 O_SENSE_CLK.n96 11.6805
R770 O_SENSE_CLK.n27 O_SENSE_CLK.n0 11.1876
R771 O_SENSE_CLK.n99 O_SENSE_CLK.n72 11.0376
R772 O_SENSE_CLK.n54 O_SENSE_CLK.n35 10.8396
R773 O_SENSE_CLK.n27 O_SENSE_CLK.n26 9.3485
R774 O_SENSE_CLK.n99 O_SENSE_CLK.n98 9.1985
R775 O_SENSE_CLK.n54 O_SENSE_CLK.n53 9.0005
R776 O_SENSE_CLK.n32 O_SENSE_CLK.n29 7.17687
R777 O_SENSE_CLK.n59 O_SENSE_CLK.n58 7.17687
R778 O_SENSE_CLK.n11 O_SENSE_CLK.n10 7.17687
R779 O_SENSE_CLK.n69 O_SENSE_CLK.n66 7.17687
R780 O_SENSE_CLK.n47 O_SENSE_CLK.n46 7.17687
R781 O_SENSE_CLK.n88 O_SENSE_CLK.n79 7.17687
R782 O_SENSE_CLK.n53 O_SENSE_CLK.n36 7.05405
R783 O_SENSE_CLK.n100 O_SENSE_CLK.n71 4.69615
R784 O_SENSE_CLK.n38 O_SENSE_CLK.n36 4.4296
R785 O_SENSE_CLK.n30 O_SENSE_CLK.n29 4.42851
R786 O_SENSE_CLK.n58 O_SENSE_CLK.n57 4.42851
R787 O_SENSE_CLK.n10 O_SENSE_CLK.n9 4.42851
R788 O_SENSE_CLK.n67 O_SENSE_CLK.n66 4.42851
R789 O_SENSE_CLK.n46 O_SENSE_CLK.n40 4.42851
R790 O_SENSE_CLK.n89 O_SENSE_CLK.n88 4.42851
R791 O_SENSE_CLK.n55 O_SENSE_CLK.n34 3.32659
R792 O_SENSE_CLK.n71 O_SENSE_CLK.n64 2.73963
R793 O_SENSE_CLK.n64 O_SENSE_CLK.n55 0.978761
R794 O_SENSE_CLK.n11 O_SENSE_CLK.n6 0.1205
R795 O_SENSE_CLK.n17 O_SENSE_CLK.n6 0.1205
R796 O_SENSE_CLK.n18 O_SENSE_CLK.n17 0.1205
R797 O_SENSE_CLK.n19 O_SENSE_CLK.n18 0.1205
R798 O_SENSE_CLK.n19 O_SENSE_CLK.n5 0.1205
R799 O_SENSE_CLK.n5 O_SENSE_CLK.n1 0.1205
R800 O_SENSE_CLK.n26 O_SENSE_CLK.n1 0.1205
R801 O_SENSE_CLK.n13 O_SENSE_CLK.n8 0.1205
R802 O_SENSE_CLK.n14 O_SENSE_CLK.n13 0.1205
R803 O_SENSE_CLK.n15 O_SENSE_CLK.n14 0.1205
R804 O_SENSE_CLK.n15 O_SENSE_CLK.n3 0.1205
R805 O_SENSE_CLK.n21 O_SENSE_CLK.n3 0.1205
R806 O_SENSE_CLK.n22 O_SENSE_CLK.n21 0.1205
R807 O_SENSE_CLK.n23 O_SENSE_CLK.n22 0.1205
R808 O_SENSE_CLK.n23 O_SENSE_CLK.n0 0.1205
R809 O_SENSE_CLK.n45 O_SENSE_CLK.n44 0.1205
R810 O_SENSE_CLK.n44 O_SENSE_CLK.n43 0.1205
R811 O_SENSE_CLK.n43 O_SENSE_CLK.n42 0.1205
R812 O_SENSE_CLK.n42 O_SENSE_CLK.n41 0.1205
R813 O_SENSE_CLK.n47 O_SENSE_CLK.n39 0.1205
R814 O_SENSE_CLK.n39 O_SENSE_CLK.n37 0.1205
R815 O_SENSE_CLK.n52 O_SENSE_CLK.n37 0.1205
R816 O_SENSE_CLK.n98 O_SENSE_CLK.n73 0.1205
R817 O_SENSE_CLK.n74 O_SENSE_CLK.n73 0.1205
R818 O_SENSE_CLK.n75 O_SENSE_CLK.n74 0.1205
R819 O_SENSE_CLK.n76 O_SENSE_CLK.n75 0.1205
R820 O_SENSE_CLK.n77 O_SENSE_CLK.n76 0.1205
R821 O_SENSE_CLK.n78 O_SENSE_CLK.n77 0.1205
R822 O_SENSE_CLK.n79 O_SENSE_CLK.n78 0.1205
R823 O_SENSE_CLK.n80 O_SENSE_CLK.n72 0.1205
R824 O_SENSE_CLK.n81 O_SENSE_CLK.n80 0.1205
R825 O_SENSE_CLK.n82 O_SENSE_CLK.n81 0.1205
R826 O_SENSE_CLK.n83 O_SENSE_CLK.n82 0.1205
R827 O_SENSE_CLK.n84 O_SENSE_CLK.n83 0.1205
R828 O_SENSE_CLK.n85 O_SENSE_CLK.n84 0.1205
R829 O_SENSE_CLK.n86 O_SENSE_CLK.n85 0.1205
R830 O_SENSE_CLK.n87 O_SENSE_CLK.n86 0.1205
R831 O_SENSE_CLK.n59 O_SENSE_CLK.n56 0.114816
R832 O_SENSE_CLK.n41 O_SENSE_CLK.n35 0.1085
R833 O_SENSE_CLK.n53 O_SENSE_CLK.n52 0.1085
R834 O_SENSE_CLK.n33 O_SENSE_CLK.n32 0.0785
R835 O_SENSE_CLK.n70 O_SENSE_CLK.n69 0.0785
R836 O_SENSE_CLK.n63 O_SENSE_CLK.n56 0.0241842
R837 E_SENSE_CLK.n58 E_SENSE_CLK.t4 139.702
R838 E_SENSE_CLK.n56 E_SENSE_CLK.t0 135.246
R839 E_SENSE_CLK.n61 E_SENSE_CLK.t1 135.246
R840 E_SENSE_CLK.n60 E_SENSE_CLK.t2 135.246
R841 E_SENSE_CLK.n59 E_SENSE_CLK.t3 135.246
R842 E_SENSE_CLK.t14 E_SENSE_CLK.n80 127.788
R843 E_SENSE_CLK.t19 E_SENSE_CLK.n42 127.788
R844 E_SENSE_CLK.t31 E_SENSE_CLK.n15 127.788
R845 E_SENSE_CLK.t26 E_SENSE_CLK.n35 127.776
R846 E_SENSE_CLK.t5 E_SENSE_CLK.n72 127.668
R847 E_SENSE_CLK.t6 E_SENSE_CLK.n95 127.668
R848 E_SENSE_CLK.n94 E_SENSE_CLK.t7 127.668
R849 E_SENSE_CLK.n93 E_SENSE_CLK.t8 127.668
R850 E_SENSE_CLK.t9 E_SENSE_CLK.n75 127.668
R851 E_SENSE_CLK.t10 E_SENSE_CLK.n87 127.668
R852 E_SENSE_CLK.n86 E_SENSE_CLK.t11 127.668
R853 E_SENSE_CLK.n85 E_SENSE_CLK.t12 127.668
R854 E_SENSE_CLK.t13 E_SENSE_CLK.n80 127.668
R855 E_SENSE_CLK.t24 E_SENSE_CLK.n49 127.668
R856 E_SENSE_CLK.t25 E_SENSE_CLK.n35 127.668
R857 E_SENSE_CLK.n42 E_SENSE_CLK.t20 127.668
R858 E_SENSE_CLK.t21 E_SENSE_CLK.n38 127.668
R859 E_SENSE_CLK.n47 E_SENSE_CLK.t22 127.668
R860 E_SENSE_CLK.n48 E_SENSE_CLK.t23 127.668
R861 E_SENSE_CLK.t40 E_SENSE_CLK.n0 127.668
R862 E_SENSE_CLK.n15 E_SENSE_CLK.t32 127.668
R863 E_SENSE_CLK.n14 E_SENSE_CLK.t33 127.668
R864 E_SENSE_CLK.n13 E_SENSE_CLK.t34 127.668
R865 E_SENSE_CLK.n12 E_SENSE_CLK.t35 127.668
R866 E_SENSE_CLK.n11 E_SENSE_CLK.t36 127.668
R867 E_SENSE_CLK.n10 E_SENSE_CLK.t37 127.668
R868 E_SENSE_CLK.n9 E_SENSE_CLK.t38 127.668
R869 E_SENSE_CLK.n8 E_SENSE_CLK.t39 127.668
R870 E_SENSE_CLK.n66 E_SENSE_CLK.t15 113.632
R871 E_SENSE_CLK.n82 E_SENSE_CLK.t14 113.632
R872 E_SENSE_CLK.n29 E_SENSE_CLK.t27 113.632
R873 E_SENSE_CLK.n43 E_SENSE_CLK.t19 113.632
R874 E_SENSE_CLK.n16 E_SENSE_CLK.t31 113.632
R875 E_SENSE_CLK.n52 E_SENSE_CLK.t26 113.629
R876 E_SENSE_CLK.n68 E_SENSE_CLK.t17 109.174
R877 E_SENSE_CLK.n69 E_SENSE_CLK.t18 109.174
R878 E_SENSE_CLK.n67 E_SENSE_CLK.t16 109.174
R879 E_SENSE_CLK.n97 E_SENSE_CLK.t5 109.174
R880 E_SENSE_CLK.n96 E_SENSE_CLK.t6 109.174
R881 E_SENSE_CLK.t7 E_SENSE_CLK.n74 109.174
R882 E_SENSE_CLK.t8 E_SENSE_CLK.n92 109.174
R883 E_SENSE_CLK.n76 E_SENSE_CLK.t9 109.174
R884 E_SENSE_CLK.n88 E_SENSE_CLK.t10 109.174
R885 E_SENSE_CLK.t11 E_SENSE_CLK.n79 109.174
R886 E_SENSE_CLK.t12 E_SENSE_CLK.n84 109.174
R887 E_SENSE_CLK.n81 E_SENSE_CLK.t13 109.174
R888 E_SENSE_CLK.n31 E_SENSE_CLK.t29 109.174
R889 E_SENSE_CLK.n32 E_SENSE_CLK.t30 109.174
R890 E_SENSE_CLK.n30 E_SENSE_CLK.t28 109.174
R891 E_SENSE_CLK.n50 E_SENSE_CLK.t24 109.174
R892 E_SENSE_CLK.n51 E_SENSE_CLK.t25 109.174
R893 E_SENSE_CLK.n44 E_SENSE_CLK.t20 109.174
R894 E_SENSE_CLK.n45 E_SENSE_CLK.t21 109.174
R895 E_SENSE_CLK.t22 E_SENSE_CLK.n46 109.174
R896 E_SENSE_CLK.t23 E_SENSE_CLK.n37 109.174
R897 E_SENSE_CLK.n25 E_SENSE_CLK.t40 109.174
R898 E_SENSE_CLK.n17 E_SENSE_CLK.t32 109.174
R899 E_SENSE_CLK.n18 E_SENSE_CLK.t33 109.174
R900 E_SENSE_CLK.n19 E_SENSE_CLK.t34 109.174
R901 E_SENSE_CLK.n20 E_SENSE_CLK.t35 109.174
R902 E_SENSE_CLK.n21 E_SENSE_CLK.t36 109.174
R903 E_SENSE_CLK.n22 E_SENSE_CLK.t37 109.174
R904 E_SENSE_CLK.n23 E_SENSE_CLK.t38 109.174
R905 E_SENSE_CLK.n24 E_SENSE_CLK.t39 109.174
R906 E_SENSE_CLK.n71 E_SENSE_CLK.n70 24.5548
R907 E_SENSE_CLK.n34 E_SENSE_CLK.n33 24.5548
R908 E_SENSE_CLK.n34 E_SENSE_CLK.n27 20.0548
R909 E_SENSE_CLK.n63 E_SENSE_CLK.n56 18.5723
R910 E_SENSE_CLK.n70 E_SENSE_CLK.n69 18.5179
R911 E_SENSE_CLK.n33 E_SENSE_CLK.n32 18.5179
R912 E_SENSE_CLK.n62 E_SENSE_CLK.n61 18.4942
R913 E_SENSE_CLK.n60 E_SENSE_CLK.n57 18.4942
R914 E_SENSE_CLK.n68 E_SENSE_CLK.n65 18.4942
R915 E_SENSE_CLK.n98 E_SENSE_CLK.n97 18.4942
R916 E_SENSE_CLK.n96 E_SENSE_CLK.n73 18.4942
R917 E_SENSE_CLK.n77 E_SENSE_CLK.n74 18.4942
R918 E_SENSE_CLK.n92 E_SENSE_CLK.n91 18.4942
R919 E_SENSE_CLK.n90 E_SENSE_CLK.n76 18.4942
R920 E_SENSE_CLK.n89 E_SENSE_CLK.n88 18.4942
R921 E_SENSE_CLK.n79 E_SENSE_CLK.n78 18.4942
R922 E_SENSE_CLK.n84 E_SENSE_CLK.n83 18.4942
R923 E_SENSE_CLK.n31 E_SENSE_CLK.n28 18.4942
R924 E_SENSE_CLK.n50 E_SENSE_CLK.n36 18.4942
R925 E_SENSE_CLK.n45 E_SENSE_CLK.n41 18.4942
R926 E_SENSE_CLK.n46 E_SENSE_CLK.n40 18.4942
R927 E_SENSE_CLK.n39 E_SENSE_CLK.n37 18.4942
R928 E_SENSE_CLK.n26 E_SENSE_CLK.n25 18.4942
R929 E_SENSE_CLK.n18 E_SENSE_CLK.n7 18.4942
R930 E_SENSE_CLK.n19 E_SENSE_CLK.n6 18.4942
R931 E_SENSE_CLK.n20 E_SENSE_CLK.n5 18.4942
R932 E_SENSE_CLK.n21 E_SENSE_CLK.n4 18.4942
R933 E_SENSE_CLK.n22 E_SENSE_CLK.n3 18.4942
R934 E_SENSE_CLK.n23 E_SENSE_CLK.n2 18.4942
R935 E_SENSE_CLK.n24 E_SENSE_CLK.n1 18.4942
R936 E_SENSE_CLK.n100 E_SENSE_CLK.n99 15.5548
R937 E_SENSE_CLK.n55 E_SENSE_CLK.n54 15.5548
R938 E_SENSE_CLK.n64 E_SENSE_CLK.n63 14.5766
R939 E_SENSE_CLK E_SENSE_CLK.n100 13.9118
R940 E_SENSE_CLK.n61 E_SENSE_CLK.n56 11.6805
R941 E_SENSE_CLK.n61 E_SENSE_CLK.n60 11.6805
R942 E_SENSE_CLK.n60 E_SENSE_CLK.n59 11.6805
R943 E_SENSE_CLK.n68 E_SENSE_CLK.n67 11.6805
R944 E_SENSE_CLK.n69 E_SENSE_CLK.n68 11.6805
R945 E_SENSE_CLK.n97 E_SENSE_CLK.n96 11.6805
R946 E_SENSE_CLK.n96 E_SENSE_CLK.n74 11.6805
R947 E_SENSE_CLK.n92 E_SENSE_CLK.n74 11.6805
R948 E_SENSE_CLK.n92 E_SENSE_CLK.n76 11.6805
R949 E_SENSE_CLK.n88 E_SENSE_CLK.n76 11.6805
R950 E_SENSE_CLK.n88 E_SENSE_CLK.n79 11.6805
R951 E_SENSE_CLK.n84 E_SENSE_CLK.n79 11.6805
R952 E_SENSE_CLK.n84 E_SENSE_CLK.n81 11.6805
R953 E_SENSE_CLK.n31 E_SENSE_CLK.n30 11.6805
R954 E_SENSE_CLK.n32 E_SENSE_CLK.n31 11.6805
R955 E_SENSE_CLK.n51 E_SENSE_CLK.n50 11.6805
R956 E_SENSE_CLK.n45 E_SENSE_CLK.n44 11.6805
R957 E_SENSE_CLK.n46 E_SENSE_CLK.n45 11.6805
R958 E_SENSE_CLK.n46 E_SENSE_CLK.n37 11.6805
R959 E_SENSE_CLK.n50 E_SENSE_CLK.n37 11.6805
R960 E_SENSE_CLK.n18 E_SENSE_CLK.n17 11.6805
R961 E_SENSE_CLK.n19 E_SENSE_CLK.n18 11.6805
R962 E_SENSE_CLK.n20 E_SENSE_CLK.n19 11.6805
R963 E_SENSE_CLK.n21 E_SENSE_CLK.n20 11.6805
R964 E_SENSE_CLK.n22 E_SENSE_CLK.n21 11.6805
R965 E_SENSE_CLK.n23 E_SENSE_CLK.n22 11.6805
R966 E_SENSE_CLK.n24 E_SENSE_CLK.n23 11.6805
R967 E_SENSE_CLK.n25 E_SENSE_CLK.n24 11.6805
R968 E_SENSE_CLK.n27 E_SENSE_CLK.n0 11.1876
R969 E_SENSE_CLK.n99 E_SENSE_CLK.n72 11.0376
R970 E_SENSE_CLK.n54 E_SENSE_CLK.n35 10.8396
R971 E_SENSE_CLK.n27 E_SENSE_CLK.n26 9.3485
R972 E_SENSE_CLK.n99 E_SENSE_CLK.n98 9.1985
R973 E_SENSE_CLK.n54 E_SENSE_CLK.n53 9.0005
R974 E_SENSE_CLK.n58 E_SENSE_CLK.n57 7.17687
R975 E_SENSE_CLK.n66 E_SENSE_CLK.n65 7.17687
R976 E_SENSE_CLK.n83 E_SENSE_CLK.n82 7.17687
R977 E_SENSE_CLK.n29 E_SENSE_CLK.n28 7.17687
R978 E_SENSE_CLK.n43 E_SENSE_CLK.n41 7.17687
R979 E_SENSE_CLK.n16 E_SENSE_CLK.n7 7.17687
R980 E_SENSE_CLK.n53 E_SENSE_CLK.n52 7.05405
R981 E_SENSE_CLK.n100 E_SENSE_CLK.n71 4.69615
R982 E_SENSE_CLK.n52 E_SENSE_CLK.n51 4.4296
R983 E_SENSE_CLK.n59 E_SENSE_CLK.n58 4.42851
R984 E_SENSE_CLK.n67 E_SENSE_CLK.n66 4.42851
R985 E_SENSE_CLK.n82 E_SENSE_CLK.n81 4.42851
R986 E_SENSE_CLK.n30 E_SENSE_CLK.n29 4.42851
R987 E_SENSE_CLK.n44 E_SENSE_CLK.n43 4.42851
R988 E_SENSE_CLK.n17 E_SENSE_CLK.n16 4.42851
R989 E_SENSE_CLK.n55 E_SENSE_CLK.n34 3.32659
R990 E_SENSE_CLK.n71 E_SENSE_CLK.n64 2.73963
R991 E_SENSE_CLK.n64 E_SENSE_CLK.n55 0.978761
R992 E_SENSE_CLK.n83 E_SENSE_CLK.n78 0.1205
R993 E_SENSE_CLK.n89 E_SENSE_CLK.n78 0.1205
R994 E_SENSE_CLK.n90 E_SENSE_CLK.n89 0.1205
R995 E_SENSE_CLK.n91 E_SENSE_CLK.n90 0.1205
R996 E_SENSE_CLK.n91 E_SENSE_CLK.n77 0.1205
R997 E_SENSE_CLK.n77 E_SENSE_CLK.n73 0.1205
R998 E_SENSE_CLK.n98 E_SENSE_CLK.n73 0.1205
R999 E_SENSE_CLK.n85 E_SENSE_CLK.n80 0.1205
R1000 E_SENSE_CLK.n86 E_SENSE_CLK.n85 0.1205
R1001 E_SENSE_CLK.n87 E_SENSE_CLK.n86 0.1205
R1002 E_SENSE_CLK.n87 E_SENSE_CLK.n75 0.1205
R1003 E_SENSE_CLK.n93 E_SENSE_CLK.n75 0.1205
R1004 E_SENSE_CLK.n94 E_SENSE_CLK.n93 0.1205
R1005 E_SENSE_CLK.n95 E_SENSE_CLK.n94 0.1205
R1006 E_SENSE_CLK.n95 E_SENSE_CLK.n72 0.1205
R1007 E_SENSE_CLK.n39 E_SENSE_CLK.n36 0.1205
R1008 E_SENSE_CLK.n40 E_SENSE_CLK.n39 0.1205
R1009 E_SENSE_CLK.n41 E_SENSE_CLK.n40 0.1205
R1010 E_SENSE_CLK.n49 E_SENSE_CLK.n48 0.1205
R1011 E_SENSE_CLK.n48 E_SENSE_CLK.n47 0.1205
R1012 E_SENSE_CLK.n47 E_SENSE_CLK.n38 0.1205
R1013 E_SENSE_CLK.n42 E_SENSE_CLK.n38 0.1205
R1014 E_SENSE_CLK.n26 E_SENSE_CLK.n1 0.1205
R1015 E_SENSE_CLK.n2 E_SENSE_CLK.n1 0.1205
R1016 E_SENSE_CLK.n3 E_SENSE_CLK.n2 0.1205
R1017 E_SENSE_CLK.n4 E_SENSE_CLK.n3 0.1205
R1018 E_SENSE_CLK.n5 E_SENSE_CLK.n4 0.1205
R1019 E_SENSE_CLK.n6 E_SENSE_CLK.n5 0.1205
R1020 E_SENSE_CLK.n7 E_SENSE_CLK.n6 0.1205
R1021 E_SENSE_CLK.n8 E_SENSE_CLK.n0 0.1205
R1022 E_SENSE_CLK.n9 E_SENSE_CLK.n8 0.1205
R1023 E_SENSE_CLK.n10 E_SENSE_CLK.n9 0.1205
R1024 E_SENSE_CLK.n11 E_SENSE_CLK.n10 0.1205
R1025 E_SENSE_CLK.n12 E_SENSE_CLK.n11 0.1205
R1026 E_SENSE_CLK.n13 E_SENSE_CLK.n12 0.1205
R1027 E_SENSE_CLK.n14 E_SENSE_CLK.n13 0.1205
R1028 E_SENSE_CLK.n15 E_SENSE_CLK.n14 0.1205
R1029 E_SENSE_CLK.n62 E_SENSE_CLK.n57 0.114816
R1030 E_SENSE_CLK.n53 E_SENSE_CLK.n36 0.1085
R1031 E_SENSE_CLK.n49 E_SENSE_CLK.n35 0.1085
R1032 E_SENSE_CLK.n70 E_SENSE_CLK.n65 0.0785
R1033 E_SENSE_CLK.n33 E_SENSE_CLK.n28 0.0785
R1034 E_SENSE_CLK.n63 E_SENSE_CLK.n62 0.0241842
R1035 VDD.t50 VDD.t49 2823.53
R1036 VDD.t52 VDD.t51 2823.53
R1037 VDD.t51 VDD.t50 1411.76
R1038 VDD.n5 VDD.t300 923.077
R1039 VDD.n6 VDD.t24 923.077
R1040 VDD.n10 VDD.t67 923.077
R1041 VDD.n11 VDD.t296 923.077
R1042 VDD.n15 VDD.t176 923.077
R1043 VDD.n16 VDD.t180 923.077
R1044 VDD.t27 VDD.t302 640.625
R1045 VDD.t70 VDD.t26 640.625
R1046 VDD.t299 VDD.t69 640.625
R1047 VDD.t179 VDD.t298 640.625
R1048 VDD.t183 VDD.t178 640.625
R1049 VDD.t3 VDD.t182 640.625
R1050 VDD.n3 VDD.t300 483.238
R1051 VDD.t24 VDD.n5 461.538
R1052 VDD.n6 VDD.t67 461.538
R1053 VDD.t296 VDD.n10 461.538
R1054 VDD.n11 VDD.t176 461.538
R1055 VDD.t180 VDD.n15 461.538
R1056 VDD.n16 VDD.t0 461.538
R1057 VDD.n28 VDD.t52 407.623
R1058 VDD.n19 VDD.t2 313.94
R1059 VDD.n338 VDD.n68 166.667
R1060 VDD.n340 VDD.n339 166.667
R1061 VDD.n361 VDD.n39 166.667
R1062 VDD.n368 VDD.n367 166.667
R1063 VDD.n210 VDD.n198 166.667
R1064 VDD.n212 VDD.n211 166.667
R1065 VDD.n233 VDD.n168 166.667
R1066 VDD.n240 VDD.n239 166.667
R1067 VDD.n339 VDD.t80 120.001
R1068 VDD.n39 VDD.t276 120.001
R1069 VDD.n211 VDD.t6 120.001
R1070 VDD.n168 VDD.t42 120.001
R1071 VDD.n347 VDD.t94 113.334
R1072 VDD.t22 VDD.t126 113.334
R1073 VDD.t133 VDD.t286 113.334
R1074 VDD.t194 VDD.n45 113.334
R1075 VDD.n219 VDD.t78 113.334
R1076 VDD.t270 VDD.t230 113.334
R1077 VDD.t237 VDD.t186 113.334
R1078 VDD.t172 VDD.n175 113.334
R1079 VDD.n333 VDD.n332 106.3
R1080 VDD.n370 VDD.n369 106.3
R1081 VDD.n205 VDD.n204 106.3
R1082 VDD.n242 VDD.n241 106.3
R1083 VDD.n340 VDD.t198 80.0005
R1084 VDD.n348 VDD.t124 80.0005
R1085 VDD.n356 VDD.t134 80.0005
R1086 VDD.n361 VDD.t63 80.0005
R1087 VDD.n212 VDD.t169 80.0005
R1088 VDD.n220 VDD.t228 80.0005
R1089 VDD.n228 VDD.t238 80.0005
R1090 VDD.n233 VDD.t86 80.0005
R1091 VDD.n333 VDD.n69 70.0005
R1092 VDD.n337 VDD.n69 70.0005
R1093 VDD.n337 VDD.n63 70.0005
R1094 VDD.n341 VDD.n63 70.0005
R1095 VDD.n341 VDD.n57 70.0005
R1096 VDD.n345 VDD.n57 70.0005
R1097 VDD.n345 VDD.n55 70.0005
R1098 VDD.n350 VDD.n55 70.0005
R1099 VDD.n350 VDD.n42 70.0005
R1100 VDD.n354 VDD.n42 70.0005
R1101 VDD.n354 VDD.n41 70.0005
R1102 VDD.n47 VDD.n41 70.0005
R1103 VDD.n47 VDD.n38 70.0005
R1104 VDD.n362 VDD.n38 70.0005
R1105 VDD.n362 VDD.n33 70.0005
R1106 VDD.n366 VDD.n33 70.0005
R1107 VDD.n366 VDD.n31 70.0005
R1108 VDD.n370 VDD.n31 70.0005
R1109 VDD.n205 VDD.n199 70.0005
R1110 VDD.n209 VDD.n199 70.0005
R1111 VDD.n209 VDD.n193 70.0005
R1112 VDD.n213 VDD.n193 70.0005
R1113 VDD.n213 VDD.n187 70.0005
R1114 VDD.n217 VDD.n187 70.0005
R1115 VDD.n217 VDD.n185 70.0005
R1116 VDD.n222 VDD.n185 70.0005
R1117 VDD.n222 VDD.n172 70.0005
R1118 VDD.n226 VDD.n172 70.0005
R1119 VDD.n226 VDD.n171 70.0005
R1120 VDD.n177 VDD.n171 70.0005
R1121 VDD.n177 VDD.n167 70.0005
R1122 VDD.n234 VDD.n167 70.0005
R1123 VDD.n234 VDD.n161 70.0005
R1124 VDD.n238 VDD.n161 70.0005
R1125 VDD.n238 VDD.n75 70.0005
R1126 VDD.n242 VDD.n75 70.0005
R1127 VDD.n332 VDD.n68 66.6672
R1128 VDD.n369 VDD.n368 66.6672
R1129 VDD.n204 VDD.n198 66.6672
R1130 VDD.n241 VDD.n240 66.6672
R1131 VDD.t302 VDD.t303 62.5005
R1132 VDD.t26 VDD.t27 62.5005
R1133 VDD.t69 VDD.t70 62.5005
R1134 VDD.t298 VDD.t299 62.5005
R1135 VDD.t178 VDD.t179 62.5005
R1136 VDD.t182 VDD.t183 62.5005
R1137 VDD.t2 VDD.t3 62.5005
R1138 VDD.n64 VDD.t278 46.6672
R1139 VDD.t46 VDD.n360 46.6672
R1140 VDD.n194 VDD.t12 46.6672
R1141 VDD.t74 VDD.n232 46.6672
R1142 VDD.n346 VDD.t116 40.0005
R1143 VDD.n46 VDD.t142 40.0005
R1144 VDD.n218 VDD.t212 40.0005
R1145 VDD.n176 VDD.t240 40.0005
R1146 VDD.t92 VDD.n348 26.6672
R1147 VDD.n356 VDD.t284 26.6672
R1148 VDD.t76 VDD.n220 26.6672
R1149 VDD.n228 VDD.t266 26.6672
R1150 VDD.n21 VDD.t160 25.1121
R1151 VDD.n23 VDD.t61 24.7565
R1152 VDD.n27 VDD.t184 24.7565
R1153 VDD.n24 VDD.t185 24.7565
R1154 VDD.n17 VDD.n16 21.6005
R1155 VDD.n15 VDD.n14 21.6005
R1156 VDD.n12 VDD.n11 21.6005
R1157 VDD.n10 VDD.n9 21.6005
R1158 VDD.n7 VDD.n6 21.6005
R1159 VDD.n5 VDD.n4 21.6005
R1160 VDD.n26 VDD.t62 21.4505
R1161 VDD.n25 VDD.t73 21.4505
R1162 VDD.n22 VDD.t171 21.3935
R1163 VDD.n21 VDD.t48 21.3935
R1164 VDD.t84 VDD.n338 20.0005
R1165 VDD.n367 VDD.t272 20.0005
R1166 VDD.t4 VDD.n210 20.0005
R1167 VDD.n239 VDD.t30 20.0005
R1168 VDD.n292 VDD.n291 19.9029
R1169 VDD.n96 VDD.n95 19.9029
R1170 VDD.n253 VDD.n252 19.8556
R1171 VDD.n137 VDD.n136 19.8556
R1172 VDD.n104 VDD.n103 19.4436
R1173 VDD.n262 VDD.n261 19.4435
R1174 VDD.n327 VDD.n326 19.0889
R1175 VDD.n78 VDD.n77 19.0889
R1176 VDD.n266 VDD.n265 19.0179
R1177 VDD.n281 VDD.n280 19.0179
R1178 VDD.n319 VDD.n318 19.0179
R1179 VDD.n250 VDD.n249 19.0179
R1180 VDD.n154 VDD.n153 19.0179
R1181 VDD.n83 VDD.n82 19.0179
R1182 VDD.n101 VDD.n100 19.0179
R1183 VDD.n118 VDD.n117 19.0179
R1184 VDD.n206 VDD.n203 18.0005
R1185 VDD.n207 VDD.n202 18.0005
R1186 VDD.n208 VDD.n201 18.0005
R1187 VDD.n200 VDD.n192 18.0005
R1188 VDD.n214 VDD.n191 18.0005
R1189 VDD.n215 VDD.n190 18.0005
R1190 VDD.n216 VDD.n189 18.0005
R1191 VDD.n188 VDD.n184 18.0005
R1192 VDD.n223 VDD.n183 18.0005
R1193 VDD.n224 VDD.n182 18.0005
R1194 VDD.n225 VDD.n181 18.0005
R1195 VDD.n180 VDD.n173 18.0005
R1196 VDD.n179 VDD.n178 18.0005
R1197 VDD.n174 VDD.n166 18.0005
R1198 VDD.n235 VDD.n165 18.0005
R1199 VDD.n236 VDD.n164 18.0005
R1200 VDD.n237 VDD.n163 18.0005
R1201 VDD.n162 VDD.n74 18.0005
R1202 VDD.n244 VDD.n243 18.0005
R1203 VDD.n334 VDD.n245 18.0005
R1204 VDD.n335 VDD.n72 18.0005
R1205 VDD.n336 VDD.n71 18.0005
R1206 VDD.n70 VDD.n62 18.0005
R1207 VDD.n342 VDD.n61 18.0005
R1208 VDD.n343 VDD.n60 18.0005
R1209 VDD.n344 VDD.n59 18.0005
R1210 VDD.n58 VDD.n54 18.0005
R1211 VDD.n351 VDD.n53 18.0005
R1212 VDD.n352 VDD.n52 18.0005
R1213 VDD.n353 VDD.n51 18.0005
R1214 VDD.n50 VDD.n43 18.0005
R1215 VDD.n49 VDD.n48 18.0005
R1216 VDD.n44 VDD.n37 18.0005
R1217 VDD.n363 VDD.n36 18.0005
R1218 VDD.n364 VDD.n35 18.0005
R1219 VDD.n365 VDD.n34 18.0005
R1220 VDD.n30 VDD.n29 18.0005
R1221 VDD.n372 VDD.n371 18.0005
R1222 VDD.n204 VDD.n197 17.639
R1223 VDD.n369 VDD.n32 17.6387
R1224 VDD.n289 VDD.n288 16.6701
R1225 VDD.n300 VDD.n299 16.6701
R1226 VDD.n142 VDD.n141 16.6701
R1227 VDD.n131 VDD.n130 16.6701
R1228 VDD.n332 VDD.n331 16.3758
R1229 VDD.n339 VDD.n67 16.3758
R1230 VDD.n66 VDD.n65 16.3758
R1231 VDD.n348 VDD.n40 16.3758
R1232 VDD.n357 VDD.n356 16.3758
R1233 VDD.n359 VDD.n358 16.3758
R1234 VDD.n39 VDD.n32 16.3758
R1235 VDD.n211 VDD.n197 16.3758
R1236 VDD.n196 VDD.n195 16.3758
R1237 VDD.n220 VDD.n170 16.3758
R1238 VDD.n229 VDD.n228 16.3758
R1239 VDD.n231 VDD.n230 16.3758
R1240 VDD.n169 VDD.n168 16.3758
R1241 VDD.n241 VDD.n160 16.3756
R1242 VDD.n258 VDD.n257 14.4407
R1243 VDD.n126 VDD.n125 14.4407
R1244 VDD.n304 VDD.n303 14.3222
R1245 VDD.n146 VDD.n145 14.3222
R1246 VDD.t82 VDD.t84 13.3338
R1247 VDD.t80 VDD.t82 13.3338
R1248 VDD.t282 VDD.t198 13.3338
R1249 VDD.t280 VDD.t282 13.3338
R1250 VDD.t278 VDD.t280 13.3338
R1251 VDD.t98 VDD.t96 13.3338
R1252 VDD.t102 VDD.t98 13.3338
R1253 VDD.t104 VDD.t102 13.3338
R1254 VDD.t106 VDD.t104 13.3338
R1255 VDD.t71 VDD.n346 13.3338
R1256 VDD.t165 VDD.t71 13.3338
R1257 VDD.t163 VDD.t165 13.3338
R1258 VDD.t94 VDD.t163 13.3338
R1259 VDD.t118 VDD.n347 13.3338
R1260 VDD.t120 VDD.t118 13.3338
R1261 VDD.t122 VDD.t120 13.3338
R1262 VDD.t124 VDD.t122 13.3338
R1263 VDD.t126 VDD.t127 13.3338
R1264 VDD.t127 VDD.t128 13.3338
R1265 VDD.t128 VDD.t129 13.3338
R1266 VDD.t130 VDD.t131 13.3338
R1267 VDD.t131 VDD.t132 13.3338
R1268 VDD.t132 VDD.t133 13.3338
R1269 VDD.t136 VDD.t134 13.3338
R1270 VDD.t100 VDD.t136 13.3338
R1271 VDD.t138 VDD.t100 13.3338
R1272 VDD.n45 VDD.t138 13.3338
R1273 VDD.t192 VDD.t194 13.3338
R1274 VDD.t290 VDD.t192 13.3338
R1275 VDD.t288 VDD.t290 13.3338
R1276 VDD.n46 VDD.t288 13.3338
R1277 VDD.t152 VDD.t146 13.3338
R1278 VDD.t154 VDD.t152 13.3338
R1279 VDD.t156 VDD.t154 13.3338
R1280 VDD.t158 VDD.t156 13.3338
R1281 VDD.t44 VDD.t46 13.3338
R1282 VDD.t65 VDD.t44 13.3338
R1283 VDD.t63 VDD.t65 13.3338
R1284 VDD.t276 VDD.t274 13.3338
R1285 VDD.t274 VDD.t272 13.3338
R1286 VDD.t161 VDD.t4 13.3338
R1287 VDD.t6 VDD.t161 13.3338
R1288 VDD.t167 VDD.t169 13.3338
R1289 VDD.t14 VDD.t167 13.3338
R1290 VDD.t12 VDD.t14 13.3338
R1291 VDD.t206 VDD.t204 13.3338
R1292 VDD.t202 VDD.t206 13.3338
R1293 VDD.t208 VDD.t202 13.3338
R1294 VDD.t210 VDD.t208 13.3338
R1295 VDD.t53 VDD.n218 13.3338
R1296 VDD.t34 VDD.t53 13.3338
R1297 VDD.t32 VDD.t34 13.3338
R1298 VDD.t78 VDD.t32 13.3338
R1299 VDD.t222 VDD.n219 13.3338
R1300 VDD.t224 VDD.t222 13.3338
R1301 VDD.t226 VDD.t224 13.3338
R1302 VDD.t228 VDD.t226 13.3338
R1303 VDD.t230 VDD.t231 13.3338
R1304 VDD.t231 VDD.t232 13.3338
R1305 VDD.t232 VDD.t233 13.3338
R1306 VDD.t234 VDD.t235 13.3338
R1307 VDD.t235 VDD.t236 13.3338
R1308 VDD.t236 VDD.t237 13.3338
R1309 VDD.t244 VDD.t238 13.3338
R1310 VDD.t246 VDD.t244 13.3338
R1311 VDD.t242 VDD.t246 13.3338
R1312 VDD.n175 VDD.t242 13.3338
R1313 VDD.t200 VDD.t172 13.3338
R1314 VDD.t196 VDD.t200 13.3338
R1315 VDD.t174 VDD.t196 13.3338
R1316 VDD.n176 VDD.t174 13.3338
R1317 VDD.t250 VDD.t258 13.3338
R1318 VDD.t260 VDD.t250 13.3338
R1319 VDD.t262 VDD.t260 13.3338
R1320 VDD.t264 VDD.t262 13.3338
R1321 VDD.t36 VDD.t74 13.3338
R1322 VDD.t18 VDD.t36 13.3338
R1323 VDD.t86 VDD.t18 13.3338
R1324 VDD.t42 VDD.t40 13.3338
R1325 VDD.t40 VDD.t30 13.3338
R1326 VDD.n3 VDD.t301 11.724
R1327 VDD.n2 VDD.t25 11.724
R1328 VDD.n8 VDD.t68 11.724
R1329 VDD.n1 VDD.t297 11.724
R1330 VDD.n13 VDD.t177 11.724
R1331 VDD.n0 VDD.t181 11.724
R1332 VDD.n18 VDD.t1 11.724
R1333 VDD.n19 VDD.n18 10.4005
R1334 VDD.n277 VDD.n276 8.55306
R1335 VDD.n114 VDD.n113 8.55306
R1336 VDD.n315 VDD.n314 8.42404
R1337 VDD.n94 VDD.n93 8.42404
R1338 VDD.t96 VDD.n64 6.66717
R1339 VDD.n65 VDD.t106 6.66717
R1340 VDD.n65 VDD.t108 6.66717
R1341 VDD.t108 VDD.t190 6.66717
R1342 VDD.t190 VDD.t110 6.66717
R1343 VDD.t110 VDD.t188 6.66717
R1344 VDD.t188 VDD.t112 6.66717
R1345 VDD.t112 VDD.t294 6.66717
R1346 VDD.t294 VDD.t114 6.66717
R1347 VDD.t114 VDD.t292 6.66717
R1348 VDD.t292 VDD.t116 6.66717
R1349 VDD.n349 VDD.t92 6.66717
R1350 VDD.n349 VDD.t22 6.66717
R1351 VDD.t129 VDD.n56 6.66717
R1352 VDD.n56 VDD.t130 6.66717
R1353 VDD.n355 VDD.t286 6.66717
R1354 VDD.t284 VDD.n355 6.66717
R1355 VDD.t142 VDD.t20 6.66717
R1356 VDD.t20 VDD.t140 6.66717
R1357 VDD.t140 VDD.t57 6.66717
R1358 VDD.t57 VDD.t144 6.66717
R1359 VDD.t144 VDD.t55 6.66717
R1360 VDD.t55 VDD.t148 6.66717
R1361 VDD.t148 VDD.t8 6.66717
R1362 VDD.t8 VDD.t150 6.66717
R1363 VDD.n359 VDD.t150 6.66717
R1364 VDD.t146 VDD.n359 6.66717
R1365 VDD.n360 VDD.t158 6.66717
R1366 VDD.t204 VDD.n194 6.66717
R1367 VDD.n195 VDD.t210 6.66717
R1368 VDD.n195 VDD.t214 6.66717
R1369 VDD.t214 VDD.t38 6.66717
R1370 VDD.t38 VDD.t216 6.66717
R1371 VDD.t216 VDD.t10 6.66717
R1372 VDD.t10 VDD.t218 6.66717
R1373 VDD.t218 VDD.t28 6.66717
R1374 VDD.t28 VDD.t220 6.66717
R1375 VDD.t220 VDD.t59 6.66717
R1376 VDD.t59 VDD.t212 6.66717
R1377 VDD.n221 VDD.t76 6.66717
R1378 VDD.n221 VDD.t270 6.66717
R1379 VDD.t233 VDD.n186 6.66717
R1380 VDD.n186 VDD.t234 6.66717
R1381 VDD.n227 VDD.t186 6.66717
R1382 VDD.t266 VDD.n227 6.66717
R1383 VDD.t240 VDD.t268 6.66717
R1384 VDD.t268 VDD.t248 6.66717
R1385 VDD.t248 VDD.t90 6.66717
R1386 VDD.t90 VDD.t252 6.66717
R1387 VDD.t252 VDD.t88 6.66717
R1388 VDD.t88 VDD.t254 6.66717
R1389 VDD.t254 VDD.t16 6.66717
R1390 VDD.t16 VDD.t256 6.66717
R1391 VDD.n231 VDD.t256 6.66717
R1392 VDD.t258 VDD.n231 6.66717
R1393 VDD.n232 VDD.t264 6.66717
R1394 VDD.n374 VDD.n373 6.5855
R1395 VDD.n371 VDD.n370 6.3005
R1396 VDD.n368 VDD.n31 6.3005
R1397 VDD.n31 VDD.n30 6.3005
R1398 VDD.n367 VDD.n366 6.3005
R1399 VDD.n366 VDD.n365 6.3005
R1400 VDD.n39 VDD.n33 6.3005
R1401 VDD.n364 VDD.n33 6.3005
R1402 VDD.n362 VDD.n361 6.3005
R1403 VDD.n363 VDD.n362 6.3005
R1404 VDD.n360 VDD.n38 6.3005
R1405 VDD.n38 VDD.n37 6.3005
R1406 VDD.n47 VDD.n46 6.3005
R1407 VDD.n48 VDD.n47 6.3005
R1408 VDD.n45 VDD.n41 6.3005
R1409 VDD.n43 VDD.n41 6.3005
R1410 VDD.n355 VDD.n354 6.3005
R1411 VDD.n354 VDD.n353 6.3005
R1412 VDD.n56 VDD.n42 6.3005
R1413 VDD.n352 VDD.n42 6.3005
R1414 VDD.n350 VDD.n349 6.3005
R1415 VDD.n351 VDD.n350 6.3005
R1416 VDD.n347 VDD.n55 6.3005
R1417 VDD.n55 VDD.n54 6.3005
R1418 VDD.n346 VDD.n345 6.3005
R1419 VDD.n345 VDD.n344 6.3005
R1420 VDD.n64 VDD.n57 6.3005
R1421 VDD.n343 VDD.n57 6.3005
R1422 VDD.n341 VDD.n340 6.3005
R1423 VDD.n342 VDD.n341 6.3005
R1424 VDD.n339 VDD.n63 6.3005
R1425 VDD.n63 VDD.n62 6.3005
R1426 VDD.n338 VDD.n337 6.3005
R1427 VDD.n337 VDD.n336 6.3005
R1428 VDD.n69 VDD.n68 6.3005
R1429 VDD.n335 VDD.n69 6.3005
R1430 VDD.n334 VDD.n333 6.3005
R1431 VDD.n206 VDD.n205 6.3005
R1432 VDD.n199 VDD.n198 6.3005
R1433 VDD.n207 VDD.n199 6.3005
R1434 VDD.n210 VDD.n209 6.3005
R1435 VDD.n209 VDD.n208 6.3005
R1436 VDD.n211 VDD.n193 6.3005
R1437 VDD.n193 VDD.n192 6.3005
R1438 VDD.n213 VDD.n212 6.3005
R1439 VDD.n214 VDD.n213 6.3005
R1440 VDD.n194 VDD.n187 6.3005
R1441 VDD.n215 VDD.n187 6.3005
R1442 VDD.n218 VDD.n217 6.3005
R1443 VDD.n217 VDD.n216 6.3005
R1444 VDD.n219 VDD.n185 6.3005
R1445 VDD.n185 VDD.n184 6.3005
R1446 VDD.n222 VDD.n221 6.3005
R1447 VDD.n223 VDD.n222 6.3005
R1448 VDD.n186 VDD.n172 6.3005
R1449 VDD.n224 VDD.n172 6.3005
R1450 VDD.n227 VDD.n226 6.3005
R1451 VDD.n226 VDD.n225 6.3005
R1452 VDD.n175 VDD.n171 6.3005
R1453 VDD.n173 VDD.n171 6.3005
R1454 VDD.n177 VDD.n176 6.3005
R1455 VDD.n178 VDD.n177 6.3005
R1456 VDD.n232 VDD.n167 6.3005
R1457 VDD.n167 VDD.n166 6.3005
R1458 VDD.n234 VDD.n233 6.3005
R1459 VDD.n235 VDD.n234 6.3005
R1460 VDD.n168 VDD.n161 6.3005
R1461 VDD.n236 VDD.n161 6.3005
R1462 VDD.n239 VDD.n238 6.3005
R1463 VDD.n238 VDD.n237 6.3005
R1464 VDD.n240 VDD.n75 6.3005
R1465 VDD.n75 VDD.n74 6.3005
R1466 VDD.n243 VDD.n242 6.3005
R1467 VDD.n261 VDD.t273 5.54817
R1468 VDD.n326 VDD.t81 5.54817
R1469 VDD.n77 VDD.t43 5.54817
R1470 VDD.n103 VDD.t5 5.54817
R1471 VDD.n261 VDD.n260 5.51014
R1472 VDD.n265 VDD.n264 5.51014
R1473 VDD.n270 VDD.n268 5.51014
R1474 VDD.n257 VDD.n255 5.51014
R1475 VDD.n288 VDD.n287 5.51014
R1476 VDD.n299 VDD.n298 5.51014
R1477 VDD.n303 VDD.n302 5.51014
R1478 VDD.n308 VDD.n306 5.51014
R1479 VDD.n318 VDD.n317 5.51014
R1480 VDD.n249 VDD.n248 5.51014
R1481 VDD.n326 VDD.n325 5.51014
R1482 VDD.n77 VDD.n76 5.51014
R1483 VDD.n153 VDD.n151 5.51014
R1484 VDD.n82 VDD.n80 5.51014
R1485 VDD.n87 VDD.n85 5.51014
R1486 VDD.n145 VDD.n143 5.51014
R1487 VDD.n141 VDD.n139 5.51014
R1488 VDD.n130 VDD.n128 5.51014
R1489 VDD.n125 VDD.n123 5.51014
R1490 VDD.n107 VDD.n105 5.51014
R1491 VDD.n117 VDD.n115 5.51014
R1492 VDD.n103 VDD.n102 5.51014
R1493 VDD.n280 VDD.n278 5.43909
R1494 VDD.n100 VDD.n99 5.43909
R1495 VDD.n280 VDD.n279 5.39172
R1496 VDD.n100 VDD.n98 5.39172
R1497 VDD.n265 VDD.n263 5.32067
R1498 VDD.n276 VDD.n275 5.32067
R1499 VDD.n274 VDD.n273 5.32067
R1500 VDD.n272 VDD.n271 5.32067
R1501 VDD.n270 VDD.n269 5.32067
R1502 VDD.n257 VDD.n256 5.32067
R1503 VDD.n288 VDD.n286 5.32067
R1504 VDD.n299 VDD.n297 5.32067
R1505 VDD.n303 VDD.n301 5.32067
R1506 VDD.n314 VDD.n313 5.32067
R1507 VDD.n312 VDD.n311 5.32067
R1508 VDD.n310 VDD.n309 5.32067
R1509 VDD.n308 VDD.n307 5.32067
R1510 VDD.n318 VDD.n316 5.32067
R1511 VDD.n249 VDD.n247 5.32067
R1512 VDD.n153 VDD.n152 5.32067
R1513 VDD.n82 VDD.n81 5.32067
R1514 VDD.n87 VDD.n86 5.32067
R1515 VDD.n89 VDD.n88 5.32067
R1516 VDD.n91 VDD.n90 5.32067
R1517 VDD.n93 VDD.n92 5.32067
R1518 VDD.n145 VDD.n144 5.32067
R1519 VDD.n141 VDD.n140 5.32067
R1520 VDD.n130 VDD.n129 5.32067
R1521 VDD.n125 VDD.n124 5.32067
R1522 VDD.n107 VDD.n106 5.32067
R1523 VDD.n109 VDD.n108 5.32067
R1524 VDD.n111 VDD.n110 5.32067
R1525 VDD.n113 VDD.n112 5.32067
R1526 VDD.n117 VDD.n116 5.32067
R1527 VDD.n20 VDD.n19 4.901
R1528 VDD.n324 VDD.n246 4.5005
R1529 VDD.n323 VDD.n322 4.5005
R1530 VDD.n321 VDD.n320 4.5005
R1531 VDD.n305 VDD.n251 4.5005
R1532 VDD.n296 VDD.n295 4.5005
R1533 VDD.n294 VDD.n293 4.5005
R1534 VDD.n290 VDD.n254 4.5005
R1535 VDD.n285 VDD.n284 4.5005
R1536 VDD.n283 VDD.n282 4.5005
R1537 VDD.n267 VDD.n259 4.5005
R1538 VDD.n133 VDD.n132 4.5005
R1539 VDD.n120 VDD.n119 4.5005
R1540 VDD.n122 VDD.n121 4.5005
R1541 VDD.n127 VDD.n97 4.5005
R1542 VDD.n135 VDD.n134 4.5005
R1543 VDD.n138 VDD.n84 4.5005
R1544 VDD.n148 VDD.n147 4.5005
R1545 VDD.n150 VDD.n149 4.5005
R1546 VDD.n155 VDD.n79 4.5005
R1547 VDD.n157 VDD.n156 4.5005
R1548 VDD.n203 VDD.n20 3.5805
R1549 VDD.n328 VDD.n327 2.48765
R1550 VDD.n158 VDD.n78 2.48765
R1551 VDD.n373 VDD.n28 2.2685
R1552 VDD.n373 VDD.n372 1.9255
R1553 VDD.n120 VDD.n104 1.76137
R1554 VDD.n262 VDD.n259 1.76125
R1555 VDD.n266 VDD.n262 1.39974
R1556 VDD.n118 VDD.n104 1.39971
R1557 VDD.n331 VDD.n67 1.26366
R1558 VDD.n67 VDD.n66 1.26366
R1559 VDD.n66 VDD.n40 1.26366
R1560 VDD.n357 VDD.n40 1.26366
R1561 VDD.n358 VDD.n357 1.26366
R1562 VDD.n358 VDD.n32 1.26366
R1563 VDD.n197 VDD.n196 1.26366
R1564 VDD.n196 VDD.n170 1.26366
R1565 VDD.n229 VDD.n170 1.26366
R1566 VDD.n230 VDD.n229 1.26366
R1567 VDD.n230 VDD.n169 1.26366
R1568 VDD.n169 VDD.n160 1.26366
R1569 VDD.n335 VDD.n334 1.0005
R1570 VDD.n336 VDD.n335 1.0005
R1571 VDD.n336 VDD.n62 1.0005
R1572 VDD.n342 VDD.n62 1.0005
R1573 VDD.n343 VDD.n342 1.0005
R1574 VDD.n344 VDD.n343 1.0005
R1575 VDD.n344 VDD.n54 1.0005
R1576 VDD.n351 VDD.n54 1.0005
R1577 VDD.n352 VDD.n351 1.0005
R1578 VDD.n353 VDD.n352 1.0005
R1579 VDD.n353 VDD.n43 1.0005
R1580 VDD.n48 VDD.n43 1.0005
R1581 VDD.n48 VDD.n37 1.0005
R1582 VDD.n363 VDD.n37 1.0005
R1583 VDD.n364 VDD.n363 1.0005
R1584 VDD.n365 VDD.n364 1.0005
R1585 VDD.n365 VDD.n30 1.0005
R1586 VDD.n371 VDD.n30 1.0005
R1587 VDD.n207 VDD.n206 1.0005
R1588 VDD.n208 VDD.n207 1.0005
R1589 VDD.n208 VDD.n192 1.0005
R1590 VDD.n214 VDD.n192 1.0005
R1591 VDD.n215 VDD.n214 1.0005
R1592 VDD.n216 VDD.n215 1.0005
R1593 VDD.n216 VDD.n184 1.0005
R1594 VDD.n223 VDD.n184 1.0005
R1595 VDD.n224 VDD.n223 1.0005
R1596 VDD.n225 VDD.n224 1.0005
R1597 VDD.n225 VDD.n173 1.0005
R1598 VDD.n178 VDD.n173 1.0005
R1599 VDD.n178 VDD.n166 1.0005
R1600 VDD.n235 VDD.n166 1.0005
R1601 VDD.n236 VDD.n235 1.0005
R1602 VDD.n237 VDD.n236 1.0005
R1603 VDD.n237 VDD.n74 1.0005
R1604 VDD.n243 VDD.n74 1.0005
R1605 VDD.n324 VDD.n323 0.9005
R1606 VDD.n156 VDD.n155 0.9005
R1607 VDD.n293 VDD.n292 0.8855
R1608 VDD.n135 VDD.n96 0.8855
R1609 VDD.n290 VDD.n289 0.8105
R1610 VDD.n132 VDD.n131 0.8105
R1611 VDD.n4 VDD.n3 0.8005
R1612 VDD.n7 VDD.n2 0.8005
R1613 VDD.n9 VDD.n8 0.8005
R1614 VDD.n12 VDD.n1 0.8005
R1615 VDD.n14 VDD.n13 0.8005
R1616 VDD.n17 VDD.n0 0.8005
R1617 VDD.n304 VDD.n300 0.7505
R1618 VDD.n146 VDD.n142 0.7505
R1619 VDD.n285 VDD.n258 0.7355
R1620 VDD.n127 VDD.n126 0.7355
R1621 VDD.n323 VDD.n250 0.6605
R1622 VDD.n155 VDD.n154 0.6605
R1623 VDD.n281 VDD.n277 0.622051
R1624 VDD.n114 VDD.n101 0.622051
R1625 VDD.n328 VDD.n246 0.608067
R1626 VDD.n158 VDD.n157 0.608067
R1627 VDD.n296 VDD.n253 0.5855
R1628 VDD.n138 VDD.n137 0.5855
R1629 VDD.n245 VDD.n244 0.5605
R1630 VDD.n320 VDD.n319 0.5105
R1631 VDD.n150 VDD.n83 0.5105
R1632 VDD.n24 VDD.n23 0.4305
R1633 VDD.n322 VDD.n246 0.4005
R1634 VDD.n322 VDD.n321 0.4005
R1635 VDD.n321 VDD.n251 0.4005
R1636 VDD.n295 VDD.n251 0.4005
R1637 VDD.n295 VDD.n294 0.4005
R1638 VDD.n294 VDD.n254 0.4005
R1639 VDD.n284 VDD.n254 0.4005
R1640 VDD.n284 VDD.n283 0.4005
R1641 VDD.n283 VDD.n259 0.4005
R1642 VDD.n121 VDD.n120 0.4005
R1643 VDD.n121 VDD.n97 0.4005
R1644 VDD.n133 VDD.n97 0.4005
R1645 VDD.n134 VDD.n133 0.4005
R1646 VDD.n134 VDD.n84 0.4005
R1647 VDD.n148 VDD.n84 0.4005
R1648 VDD.n149 VDD.n148 0.4005
R1649 VDD.n149 VDD.n79 0.4005
R1650 VDD.n157 VDD.n79 0.4005
R1651 VDD.n22 VDD.n21 0.356056
R1652 VDD.n23 VDD.n22 0.356056
R1653 VDD.n293 VDD.n253 0.3155
R1654 VDD.n137 VDD.n135 0.3155
R1655 VDD.n331 VDD.n330 0.264711
R1656 VDD.n160 VDD.n159 0.264711
R1657 VDD.n147 VDD.n94 0.256124
R1658 VDD.n315 VDD.n305 0.256124
R1659 VDD.n320 VDD.n250 0.2405
R1660 VDD.n154 VDD.n150 0.2405
R1661 VDD.n260 VDD.t277 0.228
R1662 VDD.n260 VDD.t275 0.228
R1663 VDD.n263 VDD.t66 0.228
R1664 VDD.n263 VDD.t64 0.228
R1665 VDD.n264 VDD.t47 0.228
R1666 VDD.n264 VDD.t45 0.228
R1667 VDD.n275 VDD.t157 0.228
R1668 VDD.n275 VDD.t159 0.228
R1669 VDD.n273 VDD.t153 0.228
R1670 VDD.n273 VDD.t155 0.228
R1671 VDD.n271 VDD.t151 0.228
R1672 VDD.n271 VDD.t147 0.228
R1673 VDD.n269 VDD.t145 0.228
R1674 VDD.n269 VDD.t149 0.228
R1675 VDD.n268 VDD.t143 0.228
R1676 VDD.n268 VDD.t141 0.228
R1677 VDD.n278 VDD.t56 0.228
R1678 VDD.n278 VDD.t9 0.228
R1679 VDD.n279 VDD.t21 0.228
R1680 VDD.n279 VDD.t58 0.228
R1681 VDD.n256 VDD.t291 0.228
R1682 VDD.n256 VDD.t289 0.228
R1683 VDD.n255 VDD.t195 0.228
R1684 VDD.n255 VDD.t193 0.228
R1685 VDD.n286 VDD.t101 0.228
R1686 VDD.n286 VDD.t139 0.228
R1687 VDD.n287 VDD.t135 0.228
R1688 VDD.n287 VDD.t137 0.228
R1689 VDD.n291 VDD.t287 0.228
R1690 VDD.n291 VDD.t285 0.228
R1691 VDD.n252 VDD.t93 0.228
R1692 VDD.n252 VDD.t23 0.228
R1693 VDD.n297 VDD.t123 0.228
R1694 VDD.n297 VDD.t125 0.228
R1695 VDD.n298 VDD.t119 0.228
R1696 VDD.n298 VDD.t121 0.228
R1697 VDD.n301 VDD.t164 0.228
R1698 VDD.n301 VDD.t95 0.228
R1699 VDD.n302 VDD.t72 0.228
R1700 VDD.n302 VDD.t166 0.228
R1701 VDD.n313 VDD.t115 0.228
R1702 VDD.n313 VDD.t117 0.228
R1703 VDD.n311 VDD.t111 0.228
R1704 VDD.n311 VDD.t113 0.228
R1705 VDD.n309 VDD.t107 0.228
R1706 VDD.n309 VDD.t109 0.228
R1707 VDD.n307 VDD.t103 0.228
R1708 VDD.n307 VDD.t105 0.228
R1709 VDD.n306 VDD.t97 0.228
R1710 VDD.n306 VDD.t99 0.228
R1711 VDD.n316 VDD.t295 0.228
R1712 VDD.n316 VDD.t293 0.228
R1713 VDD.n317 VDD.t191 0.228
R1714 VDD.n317 VDD.t189 0.228
R1715 VDD.n247 VDD.t281 0.228
R1716 VDD.n247 VDD.t279 0.228
R1717 VDD.n248 VDD.t199 0.228
R1718 VDD.n248 VDD.t283 0.228
R1719 VDD.n325 VDD.t85 0.228
R1720 VDD.n325 VDD.t83 0.228
R1721 VDD.n76 VDD.t41 0.228
R1722 VDD.n76 VDD.t31 0.228
R1723 VDD.n151 VDD.t19 0.228
R1724 VDD.n151 VDD.t87 0.228
R1725 VDD.n152 VDD.t75 0.228
R1726 VDD.n152 VDD.t37 0.228
R1727 VDD.n80 VDD.t89 0.228
R1728 VDD.n80 VDD.t17 0.228
R1729 VDD.n81 VDD.t269 0.228
R1730 VDD.n81 VDD.t91 0.228
R1731 VDD.n85 VDD.t263 0.228
R1732 VDD.n85 VDD.t265 0.228
R1733 VDD.n86 VDD.t251 0.228
R1734 VDD.n86 VDD.t261 0.228
R1735 VDD.n88 VDD.t257 0.228
R1736 VDD.n88 VDD.t259 0.228
R1737 VDD.n90 VDD.t253 0.228
R1738 VDD.n90 VDD.t255 0.228
R1739 VDD.n92 VDD.t241 0.228
R1740 VDD.n92 VDD.t249 0.228
R1741 VDD.n143 VDD.t197 0.228
R1742 VDD.n143 VDD.t175 0.228
R1743 VDD.n144 VDD.t173 0.228
R1744 VDD.n144 VDD.t201 0.228
R1745 VDD.n139 VDD.t247 0.228
R1746 VDD.n139 VDD.t243 0.228
R1747 VDD.n140 VDD.t239 0.228
R1748 VDD.n140 VDD.t245 0.228
R1749 VDD.n136 VDD.t187 0.228
R1750 VDD.n136 VDD.t267 0.228
R1751 VDD.n95 VDD.t77 0.228
R1752 VDD.n95 VDD.t271 0.228
R1753 VDD.n128 VDD.t227 0.228
R1754 VDD.n128 VDD.t229 0.228
R1755 VDD.n129 VDD.t223 0.228
R1756 VDD.n129 VDD.t225 0.228
R1757 VDD.n123 VDD.t33 0.228
R1758 VDD.n123 VDD.t79 0.228
R1759 VDD.n124 VDD.t54 0.228
R1760 VDD.n124 VDD.t35 0.228
R1761 VDD.n98 VDD.t29 0.228
R1762 VDD.n98 VDD.t60 0.228
R1763 VDD.n99 VDD.t39 0.228
R1764 VDD.n99 VDD.t11 0.228
R1765 VDD.n105 VDD.t221 0.228
R1766 VDD.n105 VDD.t213 0.228
R1767 VDD.n106 VDD.t217 0.228
R1768 VDD.n106 VDD.t219 0.228
R1769 VDD.n108 VDD.t211 0.228
R1770 VDD.n108 VDD.t215 0.228
R1771 VDD.n110 VDD.t203 0.228
R1772 VDD.n110 VDD.t209 0.228
R1773 VDD.n112 VDD.t205 0.228
R1774 VDD.n112 VDD.t207 0.228
R1775 VDD.n115 VDD.t15 0.228
R1776 VDD.n115 VDD.t13 0.228
R1777 VDD.n116 VDD.t170 0.228
R1778 VDD.n116 VDD.t168 0.228
R1779 VDD.n102 VDD.t162 0.228
R1780 VDD.n102 VDD.t7 0.228
R1781 VDD.n272 VDD.n270 0.189974
R1782 VDD.n274 VDD.n272 0.189974
R1783 VDD.n276 VDD.n274 0.189974
R1784 VDD.n310 VDD.n308 0.189974
R1785 VDD.n312 VDD.n310 0.189974
R1786 VDD.n314 VDD.n312 0.189974
R1787 VDD.n93 VDD.n91 0.189974
R1788 VDD.n91 VDD.n89 0.189974
R1789 VDD.n89 VDD.n87 0.189974
R1790 VDD.n113 VDD.n111 0.189974
R1791 VDD.n111 VDD.n109 0.189974
R1792 VDD.n109 VDD.n107 0.189974
R1793 VDD.n327 VDD.n324 0.1655
R1794 VDD.n282 VDD.n258 0.1655
R1795 VDD.n126 VDD.n122 0.1655
R1796 VDD.n156 VDD.n78 0.1655
R1797 VDD.n277 VDD.n267 0.143825
R1798 VDD.n119 VDD.n114 0.143825
R1799 VDD.n330 VDD.n328 0.143727
R1800 VDD.n159 VDD.n158 0.143727
R1801 VDD.n282 VDD.n281 0.1355
R1802 VDD.n122 VDD.n101 0.1355
R1803 VDD.n319 VDD.n315 0.135448
R1804 VDD.n94 VDD.n83 0.135448
R1805 VDD.n374 VDD.n20 0.1105
R1806 VDD.n4 VDD.n2 0.1005
R1807 VDD.n8 VDD.n7 0.1005
R1808 VDD.n9 VDD.n1 0.1005
R1809 VDD.n13 VDD.n12 0.1005
R1810 VDD.n14 VDD.n0 0.1005
R1811 VDD.n18 VDD.n17 0.1005
R1812 VDD.n203 VDD.n202 0.1005
R1813 VDD.n202 VDD.n201 0.1005
R1814 VDD.n201 VDD.n200 0.1005
R1815 VDD.n200 VDD.n191 0.1005
R1816 VDD.n191 VDD.n190 0.1005
R1817 VDD.n190 VDD.n189 0.1005
R1818 VDD.n189 VDD.n188 0.1005
R1819 VDD.n188 VDD.n183 0.1005
R1820 VDD.n183 VDD.n182 0.1005
R1821 VDD.n182 VDD.n181 0.1005
R1822 VDD.n181 VDD.n180 0.1005
R1823 VDD.n180 VDD.n179 0.1005
R1824 VDD.n179 VDD.n174 0.1005
R1825 VDD.n174 VDD.n165 0.1005
R1826 VDD.n165 VDD.n164 0.1005
R1827 VDD.n164 VDD.n163 0.1005
R1828 VDD.n163 VDD.n162 0.1005
R1829 VDD.n72 VDD.n71 0.1005
R1830 VDD.n71 VDD.n70 0.1005
R1831 VDD.n70 VDD.n61 0.1005
R1832 VDD.n61 VDD.n60 0.1005
R1833 VDD.n60 VDD.n59 0.1005
R1834 VDD.n59 VDD.n58 0.1005
R1835 VDD.n58 VDD.n53 0.1005
R1836 VDD.n53 VDD.n52 0.1005
R1837 VDD.n52 VDD.n51 0.1005
R1838 VDD.n51 VDD.n50 0.1005
R1839 VDD.n50 VDD.n49 0.1005
R1840 VDD.n49 VDD.n44 0.1005
R1841 VDD.n44 VDD.n36 0.1005
R1842 VDD.n36 VDD.n35 0.1005
R1843 VDD.n35 VDD.n34 0.1005
R1844 VDD.n34 VDD.n29 0.1005
R1845 VDD.n372 VDD.n29 0.1005
R1846 VDD.n300 VDD.n296 0.0905
R1847 VDD.n289 VDD.n285 0.0905
R1848 VDD.n131 VDD.n127 0.0905
R1849 VDD.n142 VDD.n138 0.0905
R1850 VDD.n25 VDD.n24 0.0805
R1851 VDD.n26 VDD.n25 0.0805
R1852 VDD.n27 VDD.n26 0.0805
R1853 VDD.n330 VDD.n329 0.0741842
R1854 VDD.n159 VDD.n73 0.0741842
R1855 VDD.n162 VDD.n73 0.0705
R1856 VDD.n329 VDD.n72 0.0705
R1857 VDD.n305 VDD.n304 0.0605
R1858 VDD.n267 VDD.n266 0.0605
R1859 VDD.n119 VDD.n118 0.0605
R1860 VDD.n147 VDD.n146 0.0605
R1861 VDD.n28 VDD.n27 0.0325
R1862 VDD.n244 VDD.n73 0.0305
R1863 VDD.n329 VDD.n245 0.0305
R1864 VDD VDD.n374 0.0205
R1865 VDD.n292 VDD.n290 0.0155
R1866 VDD.n132 VDD.n96 0.0155
R1867 VSS.n179 VSS.n178 636119
R1868 VSS.n620 VSS.n179 626886
R1869 VSS.n400 VSS.t268 48139.4
R1870 VSS.n401 VSS.n400 47272.7
R1871 VSS.n712 VSS.n179 12088.4
R1872 VSS.n670 VSS.n200 5590
R1873 VSS.t101 VSS.t188 3033.33
R1874 VSS.n490 VSS.n488 3018.12
R1875 VSS.n282 VSS.n179 2622.35
R1876 VSS.t188 VSS.t97 1733.33
R1877 VSS.n686 VSS.n192 1618.73
R1878 VSS.n191 VSS.t101 1462.5
R1879 VSS.t97 VSS.t195 1300
R1880 VSS.n409 VSS.n408 1266.62
R1881 VSS.t268 VSS.n200 996.668
R1882 VSS.t99 VSS.t4 878.379
R1883 VSS.n408 VSS.n381 780
R1884 VSS.n464 VSS.n235 780
R1885 VSS.n402 VSS.n247 780
R1886 VSS.n464 VSS.n463 715
R1887 VSS.n670 VSS.n191 617.5
R1888 VSS.n401 VSS.n381 507
R1889 VSS.t4 VSS.t105 501.932
R1890 VSS.n191 VSS.t99 423.505
R1891 VSS.n488 VSS.n235 401.685
R1892 VSS.t105 VSS.t213 376.449
R1893 VSS.n463 VSS.t77 330.079
R1894 VSS.n413 VSS.n378 296.139
R1895 VSS.n419 VSS.n374 296.139
R1896 VSS.n426 VSS.n422 296.139
R1897 VSS.n425 VSS.n424 296.139
R1898 VSS.n433 VSS.n432 296.139
R1899 VSS.n435 VSS.n434 296.139
R1900 VSS.n463 VSS.t2 279.298
R1901 VSS.n402 VSS.n401 273
R1902 VSS.n440 VSS.n437 204.55
R1903 VSS.n686 VSS.n191 178.814
R1904 VSS.n287 VSS.n260 169.565
R1905 VSS.n621 VSS.n494 164.142
R1906 VSS.n627 VSS.n494 164.142
R1907 VSS.n410 VSS.n409 163.127
R1908 VSS.n513 VSS.n512 131.314
R1909 VSS.n647 VSS.n221 131.314
R1910 VSS.n281 VSS.n271 121.016
R1911 VSS.n275 VSS.n271 121.016
R1912 VSS.t233 VSS.n628 118.183
R1913 VSS.n437 VSS.n192 116.713
R1914 VSS.n745 VSS.n108 113.24
R1915 VSS.n751 VSS.n108 113.24
R1916 VSS.n151 VSS.n125 113.24
R1917 VSS.n125 VSS.n115 113.24
R1918 VSS.n628 VSS.t284 111.617
R1919 VSS.n411 VSS.n410 107.915
R1920 VSS.n413 VSS.n412 107.915
R1921 VSS.n420 VSS.n419 107.915
R1922 VSS.n422 VSS.n421 107.915
R1923 VSS.n424 VSS.n423 107.915
R1924 VSS.n432 VSS.n369 107.915
R1925 VSS.n440 VSS.n439 107.915
R1926 VSS.n320 VSS.n256 92.6738
R1927 VSS.n294 VSS.n256 92.6738
R1928 VSS.n649 VSS.t203 91.9197
R1929 VSS.n437 VSS.n366 91.1502
R1930 VSS.n100 VSS.n86 90.5928
R1931 VSS.n770 VSS.n87 90.5928
R1932 VSS.n463 VSS.n462 90.2783
R1933 VSS.n606 VSS.n605 87.5005
R1934 VSS.n610 VSS.n609 87.5005
R1935 VSS.n614 VSS.n613 87.5005
R1936 VSS.n618 VSS.n504 87.5005
R1937 VSS.n509 VSS.n498 87.5005
R1938 VSS.n509 VSS.n493 87.5005
R1939 VSS.n493 VSS.n492 87.5005
R1940 VSS.n492 VSS.n491 87.5005
R1941 VSS.n491 VSS.n229 87.5005
R1942 VSS.n636 VSS.n229 87.5005
R1943 VSS.n636 VSS.n226 87.5005
R1944 VSS.n640 VSS.n226 87.5005
R1945 VSS.n640 VSS.n225 87.5005
R1946 VSS.n352 VSS.n225 87.5005
R1947 VSS.n352 VSS.n220 87.5005
R1948 VSS.n220 VSS.n219 87.5005
R1949 VSS.n219 VSS.n218 87.5005
R1950 VSS.n358 VSS.n218 87.5005
R1951 VSS.n358 VSS.n211 87.5005
R1952 VSS.n349 VSS.n211 87.5005
R1953 VSS.n349 VSS.n250 87.5005
R1954 VSS.n295 VSS.n250 87.5005
R1955 VSS.n300 VSS.n299 87.5005
R1956 VSS.n304 VSS.n303 87.5005
R1957 VSS.n308 VSS.n307 87.5005
R1958 VSS.n312 VSS.n266 87.5005
R1959 VSS.n312 VSS.n259 87.5005
R1960 VSS.n622 VSS.n495 87.5005
R1961 VSS.n626 VSS.n495 87.5005
R1962 VSS.n626 VSS.n234 87.5005
R1963 VSS.n630 VSS.n234 87.5005
R1964 VSS.n630 VSS.n231 87.5005
R1965 VSS.n634 VSS.n231 87.5005
R1966 VSS.n634 VSS.n230 87.5005
R1967 VSS.n230 VSS.n224 87.5005
R1968 VSS.n642 VSS.n224 87.5005
R1969 VSS.n642 VSS.n222 87.5005
R1970 VSS.n646 VSS.n222 87.5005
R1971 VSS.n646 VSS.n217 87.5005
R1972 VSS.n650 VSS.n217 87.5005
R1973 VSS.n650 VSS.n214 87.5005
R1974 VSS.n654 VSS.n214 87.5005
R1975 VSS.n654 VSS.n213 87.5005
R1976 VSS.n319 VSS.n213 87.5005
R1977 VSS.n319 VSS.n257 87.5005
R1978 VSS.n746 VSS.n109 87.5005
R1979 VSS.n750 VSS.n109 87.5005
R1980 VSS.n750 VSS.n103 87.5005
R1981 VSS.n754 VSS.n103 87.5005
R1982 VSS.n754 VSS.n101 87.5005
R1983 VSS.n758 VSS.n101 87.5005
R1984 VSS.n758 VSS.n93 87.5005
R1985 VSS.n765 VSS.n93 87.5005
R1986 VSS.n765 VSS.n90 87.5005
R1987 VSS.n769 VSS.n90 87.5005
R1988 VSS.n769 VSS.n89 87.5005
R1989 VSS.n142 VSS.n89 87.5005
R1990 VSS.n142 VSS.n130 87.5005
R1991 VSS.n146 VSS.n130 87.5005
R1992 VSS.n146 VSS.n127 87.5005
R1993 VSS.n150 VSS.n127 87.5005
R1994 VSS.n150 VSS.n126 87.5005
R1995 VSS.n126 VSS.n120 87.5005
R1996 VSS.n161 VSS.n160 87.5005
R1997 VSS.n165 VSS.n164 87.5005
R1998 VSS.n169 VSS.n168 87.5005
R1999 VSS.n171 VSS.n118 87.5005
R2000 VSS.n119 VSS.n118 87.5005
R2001 VSS.n723 VSS.n112 87.5005
R2002 VSS.n723 VSS.n107 87.5005
R2003 VSS.n107 VSS.n106 87.5005
R2004 VSS.n106 VSS.n105 87.5005
R2005 VSS.n105 VSS.n99 87.5005
R2006 VSS.n760 VSS.n99 87.5005
R2007 VSS.n760 VSS.n96 87.5005
R2008 VSS.n764 VSS.n96 87.5005
R2009 VSS.n764 VSS.n95 87.5005
R2010 VSS.n95 VSS.n88 87.5005
R2011 VSS.n134 VSS.n88 87.5005
R2012 VSS.n140 VSS.n134 87.5005
R2013 VSS.n140 VSS.n133 87.5005
R2014 VSS.n133 VSS.n132 87.5005
R2015 VSS.n132 VSS.n124 87.5005
R2016 VSS.n152 VSS.n124 87.5005
R2017 VSS.n152 VSS.n122 87.5005
R2018 VSS.n156 VSS.n122 87.5005
R2019 VSS.n730 VSS.n729 87.5005
R2020 VSS.n734 VSS.n733 87.5005
R2021 VSS.n738 VSS.n737 87.5005
R2022 VSS.n742 VSS.n718 87.5005
R2023 VSS.t117 VSS.t28 85.354
R2024 VSS.n641 VSS.t242 85.354
R2025 VSS.t184 VSS.n752 81.5336
R2026 VSS.t360 VSS.n131 81.5336
R2027 VSS.n286 VSS.n285 78.8053
R2028 VSS.n752 VSS.t22 77.004
R2029 VSS.n131 VSS.t293 77.004
R2030 VSS.n362 VSS.n241 77.0005
R2031 VSS.n321 VSS.n251 76.8701
R2032 VSS.n621 VSS.n620 75.5056
R2033 VSS.n361 VSS.n360 75.5056
R2034 VSS.n656 VSS.n655 72.2227
R2035 VSS.n445 VSS.n366 68.2505
R2036 VSS.n602 VSS.n498 68.2505
R2037 VSS.n296 VSS.n295 68.2505
R2038 VSS.n157 VSS.n156 68.2505
R2039 VSS.n726 VSS.n112 68.2505
R2040 VSS.n313 VSS.n260 67.8266
R2041 VSS.n463 VSS.n247 65.0005
R2042 VSS.n322 VSS.n321 64.4129
R2043 VSS.n104 VSS.t303 63.4151
R2044 VSS.n285 VSS.n284 62.7396
R2045 VSS.n438 VSS.n184 60.8596
R2046 VSS.n467 VSS.n466 59.5005
R2047 VSS.n345 VSS.n253 59.5005
R2048 VSS.n709 VSS.n187 59.5005
R2049 VSS.t11 VSS.n648 59.0914
R2050 VSS.t197 VSS.t295 58.8855
R2051 VSS.n94 VSS.t87 58.8855
R2052 VSS.t366 VSS.t65 58.8855
R2053 VSS.n411 VSS.t297 55.2129
R2054 VSS.n412 VSS.t95 55.2129
R2055 VSS.n378 VSS.t298 55.2129
R2056 VSS.t182 VSS.n374 55.2129
R2057 VSS.n420 VSS.t69 55.2129
R2058 VSS.n421 VSS.t172 55.2129
R2059 VSS.t266 VSS.n426 55.2129
R2060 VSS.n425 VSS.t253 55.2129
R2061 VSS.n423 VSS.t201 55.2129
R2062 VSS.t283 VSS.n369 55.2129
R2063 VSS.n433 VSS.t211 55.2129
R2064 VSS.n434 VSS.t64 55.2129
R2065 VSS.n438 VSS.t212 55.2129
R2066 VSS.n439 VSS.t196 55.2129
R2067 VSS.n414 VSS.n377 52.5005
R2068 VSS.n414 VSS.n375 52.5005
R2069 VSS.n418 VSS.n375 52.5005
R2070 VSS.n418 VSS.n373 52.5005
R2071 VSS.n427 VSS.n373 52.5005
R2072 VSS.n427 VSS.n370 52.5005
R2073 VSS.n431 VSS.n370 52.5005
R2074 VSS.n431 VSS.n368 52.5005
R2075 VSS.n436 VSS.n368 52.5005
R2076 VSS.n441 VSS.n436 52.5005
R2077 VSS.n441 VSS.n366 52.5005
R2078 VSS.n466 VSS.n465 52.5005
R2079 VSS.n465 VSS.n245 52.5005
R2080 VSS.n403 VSS.n245 52.5005
R2081 VSS.n403 VSS.n383 52.5005
R2082 VSS.n407 VSS.n383 52.5005
R2083 VSS.n407 VSS.n382 52.5005
R2084 VSS.n396 VSS.n395 52.5005
R2085 VSS.n471 VSS.n470 52.5005
R2086 VSS.n475 VSS.n474 52.5005
R2087 VSS.n479 VSS.n478 52.5005
R2088 VSS.n483 VSS.n482 52.5005
R2089 VSS.n487 VSS.n242 52.5005
R2090 VSS.n487 VSS.n241 52.5005
R2091 VSS.n461 VSS.n362 52.5005
R2092 VSS.n461 VSS.n248 52.5005
R2093 VSS.n456 VSS.n248 52.5005
R2094 VSS.n456 VSS.n455 52.5005
R2095 VSS.n453 VSS.n364 52.5005
R2096 VSS.n449 VSS.n447 52.5005
R2097 VSS.n671 VSS.n199 52.5005
R2098 VSS.n672 VSS.n671 52.5005
R2099 VSS.n676 VSS.n675 52.5005
R2100 VSS.n680 VSS.n679 52.5005
R2101 VSS.n684 VSS.n196 52.5005
R2102 VSS.n658 VSS.n205 52.5005
R2103 VSS.n329 VSS.n328 52.5005
R2104 VSS.n337 VSS.n336 52.5005
R2105 VSS.n341 VSS.n340 52.5005
R2106 VSS.n345 VSS.n252 52.5005
R2107 VSS.n324 VSS.n252 52.5005
R2108 VSS.n324 VSS.n255 52.5005
R2109 VSS.n292 VSS.n255 52.5005
R2110 VSS.n292 VSS.n268 52.5005
R2111 VSS.n288 VSS.n268 52.5005
R2112 VSS.n288 VSS.n270 52.5005
R2113 VSS.n280 VSS.n270 52.5005
R2114 VSS.n280 VSS.n272 52.5005
R2115 VSS.n276 VSS.n272 52.5005
R2116 VSS.n697 VSS.n696 52.5005
R2117 VSS.n699 VSS.n181 52.5005
R2118 VSS.n702 VSS.n181 52.5005
R2119 VSS.n704 VSS.n185 52.5005
R2120 VSS.n186 VSS.n185 52.5005
R2121 VSS.n745 VSS.n744 52.0911
R2122 VSS.n178 VSS.n115 52.0911
R2123 VSS.n744 VSS.n712 50.9587
R2124 VSS.n273 VSS.n184 50.8701
R2125 VSS.n400 VSS.t77 50.7817
R2126 VSS.n392 VSS.n377 50.7505
R2127 VSS.n668 VSS.n201 50.7505
R2128 VSS.n688 VSS.n687 50.7505
R2129 VSS.n622 VSS.n497 50.7505
R2130 VSS.n315 VSS.n257 50.7505
R2131 VSS.n176 VSS.n120 50.7505
R2132 VSS.n746 VSS.n111 50.7505
R2133 VSS.n284 VSS.t177 50.3048
R2134 VSS.n435 VSS.n184 47.0565
R2135 VSS.n759 VSS.t301 40.7671
R2136 VSS.n712 VSS.n711 37.3698
R2137 VSS.n687 VSS.n190 35.0005
R2138 VSS.n276 VSS.n187 35.0005
R2139 VSS.n649 VSS.t191 32.8288
R2140 VSS.n771 VSS.n86 29.6637
R2141 VSS.n514 VSS.n221 29.6637
R2142 VSS.t28 VSS.n490 28.7252
R2143 VSS.n514 VSS.n513 28.4005
R2144 VSS.n771 VSS.n770 28.4005
R2145 VSS.n323 VSS.n320 28.2614
R2146 VSS.n294 VSS.n293 28.2614
R2147 VSS.n666 VSS.n203 27.8548
R2148 VSS.t79 VSS.t281 26.2631
R2149 VSS.n503 VSS.n497 26.2505
R2150 VSS.n717 VSS.n111 26.2505
R2151 VSS.n282 VSS.t177 25.4353
R2152 VSS.t297 VSS.t252 25.097
R2153 VSS.t252 VSS.t95 25.097
R2154 VSS.t298 VSS.t121 25.097
R2155 VSS.t121 VSS.t182 25.097
R2156 VSS.t69 VSS.t49 25.097
R2157 VSS.t49 VSS.t172 25.097
R2158 VSS.t286 VSS.t266 25.097
R2159 VSS.t286 VSS.t253 25.097
R2160 VSS.t201 VSS.t171 25.097
R2161 VSS.t171 VSS.t283 25.097
R2162 VSS.t211 VSS.t122 25.097
R2163 VSS.t122 VSS.t64 25.097
R2164 VSS.t212 VSS.t267 25.097
R2165 VSS.t267 VSS.t196 25.097
R2166 VSS.n283 VSS.n282 24.8701
R2167 VSS.n322 VSS.t50 24.3168
R2168 VSS.n256 VSS.t251 24.3168
R2169 VSS.t78 VSS.n271 24.2761
R2170 VSS.n579 VSS.t29 23.9124
R2171 VSS.n8 VSS.t66 23.9124
R2172 VSS.n548 VSS.t192 23.8177
R2173 VSS.n32 VSS.t296 23.8177
R2174 VSS.n565 VSS.n564 23.8024
R2175 VSS.n68 VSS.n67 23.8024
R2176 VSS.n534 VSS.n533 23.7551
R2177 VSS.n18 VSS.n17 23.7551
R2178 VSS.t295 VSS.n104 22.6486
R2179 VSS.t65 VSS.n144 22.6486
R2180 VSS.t32 VSS.n191 22.6092
R2181 VSS.n348 VSS.t369 22.6092
R2182 VSS.n293 VSS.n262 22.2836
R2183 VSS.n287 VSS.n286 22.2836
R2184 VSS.n275 VSS.n274 22.2836
R2185 VSS.n274 VSS.n273 22.2836
R2186 VSS.n601 VSS.n600 21.0437
R2187 VSS.n772 VSS.n2 21.0437
R2188 VSS.n513 VSS.t235 19.6975
R2189 VSS.t86 VSS.n221 19.6975
R2190 VSS.n391 VSS.n390 19.4846
R2191 VSS.t371 VSS.n347 19.2179
R2192 VSS.n22 VSS.n21 18.5679
R2193 VSS.n538 VSS.n537 18.5679
R2194 VSS.n81 VSS.n80 18.2754
R2195 VSS.n31 VSS.n30 18.2754
R2196 VSS.n547 VSS.n546 18.2754
R2197 VSS.n586 VSS.n580 18.2754
R2198 VSS.n544 VSS.n539 18.157
R2199 VSS.n588 VSS.n587 18.157
R2200 VSS.n597 VSS.n596 18.157
R2201 VSS.n7 VSS.n6 18.157
R2202 VSS.n78 VSS.n73 18.157
R2203 VSS.n28 VSS.n23 18.157
R2204 VSS.t218 VSS.t250 18.119
R2205 VSS.n262 VSS.t74 17.1206
R2206 VSS.n286 VSS.t257 17.1206
R2207 VSS.n274 VSS.t256 17.1206
R2208 VSS.t30 VSS.n346 16.957
R2209 VSS.t228 VSS.t371 16.957
R2210 VSS.n655 VSS.n212 16.4146
R2211 VSS.n206 VSS.n191 16.4146
R2212 VSS.n774 VSS.n773 15.7399
R2213 VSS.n384 VSS.t3 15.202
R2214 VSS.n384 VSS.t255 14.302
R2215 VSS.n385 VSS.t254 14.302
R2216 VSS.n386 VSS.t353 14.302
R2217 VSS.n387 VSS.t96 14.302
R2218 VSS.n388 VSS.t21 14.302
R2219 VSS.n389 VSS.t368 14.302
R2220 VSS.t243 VSS.n86 13.5894
R2221 VSS.n770 VSS.t94 13.5894
R2222 VSS.t123 VSS.n627 13.1318
R2223 VSS.t55 VSS.t123 13.1318
R2224 VSS.t17 VSS.t55 13.1318
R2225 VSS.t284 VSS.t17 13.1318
R2226 VSS.t289 VSS.t233 13.1318
R2227 VSS.t299 VSS.t289 13.1318
R2228 VSS.t258 VSS.t299 13.1318
R2229 VSS.t287 VSS.t356 13.1318
R2230 VSS.t356 VSS.t260 13.1318
R2231 VSS.t260 VSS.t117 13.1318
R2232 VSS.n489 VSS.t125 13.1318
R2233 VSS.t125 VSS.t127 13.1318
R2234 VSS.t127 VSS.t129 13.1318
R2235 VSS.t129 VSS.t131 13.1318
R2236 VSS.t131 VSS.t133 13.1318
R2237 VSS.t133 VSS.t135 13.1318
R2238 VSS.t135 VSS.t36 13.1318
R2239 VSS.t36 VSS.t9 13.1318
R2240 VSS.t9 VSS.t139 13.1318
R2241 VSS.t139 VSS.t141 13.1318
R2242 VSS.t141 VSS.t143 13.1318
R2243 VSS.t143 VSS.t145 13.1318
R2244 VSS.t236 VSS.t235 13.1318
R2245 VSS.t237 VSS.t236 13.1318
R2246 VSS.t238 VSS.t237 13.1318
R2247 VSS.t239 VSS.t238 13.1318
R2248 VSS.t240 VSS.t239 13.1318
R2249 VSS.t241 VSS.t240 13.1318
R2250 VSS.t242 VSS.t241 13.1318
R2251 VSS.t277 VSS.t275 13.1318
R2252 VSS.t273 VSS.t277 13.1318
R2253 VSS.t279 VSS.t273 13.1318
R2254 VSS.t281 VSS.t279 13.1318
R2255 VSS.t80 VSS.t79 13.1318
R2256 VSS.t81 VSS.t80 13.1318
R2257 VSS.t82 VSS.t81 13.1318
R2258 VSS.t83 VSS.t82 13.1318
R2259 VSS.t84 VSS.t83 13.1318
R2260 VSS.t85 VSS.t84 13.1318
R2261 VSS.t85 VSS.t86 13.1318
R2262 VSS.t26 VSS.t27 13.1318
R2263 VSS.t68 VSS.t26 13.1318
R2264 VSS.t67 VSS.t68 13.1318
R2265 VSS.t190 VSS.t67 13.1318
R2266 VSS.t189 VSS.t190 13.1318
R2267 VSS.t194 VSS.t189 13.1318
R2268 VSS.t193 VSS.t194 13.1318
R2269 VSS.t179 VSS.t193 13.1318
R2270 VSS.t178 VSS.t179 13.1318
R2271 VSS.t39 VSS.t178 13.1318
R2272 VSS.t38 VSS.t39 13.1318
R2273 VSS.t203 VSS.t11 13.1318
R2274 VSS.t175 VSS.t115 13.1318
R2275 VSS.t115 VSS.t364 13.1318
R2276 VSS.t364 VSS.t42 13.1318
R2277 VSS.t13 VSS.t173 13.1318
R2278 VSS.t173 VSS.t40 13.1318
R2279 VSS.t40 VSS.t119 13.1318
R2280 VSS.n558 VSS.n557 11.7005
R2281 VSS.n567 VSS.n566 11.7005
R2282 VSS.n578 VSS.n577 11.7005
R2283 VSS.n50 VSS.n10 11.7005
R2284 VSS.n66 VSS.n65 11.7005
R2285 VSS.n15 VSS.n14 11.7005
R2286 VSS.n313 VSS.n262 10.9792
R2287 VSS.t149 VSS.t202 9.84898
R2288 VSS.t151 VSS.t63 9.84898
R2289 VSS.t153 VSS.t62 9.84898
R2290 VSS.t155 VSS.t52 9.84898
R2291 VSS.t157 VSS.t51 9.84898
R2292 VSS.t159 VSS.t35 9.84898
R2293 VSS.t161 VSS.t34 9.84898
R2294 VSS.t163 VSS.t181 9.84898
R2295 VSS.t165 VSS.t180 9.84898
R2296 VSS.t167 VSS.t215 9.84898
R2297 VSS.t169 VSS.t214 9.84898
R2298 VSS.n512 VSS.t183 9.84898
R2299 VSS.t27 VSS.n647 9.84898
R2300 VSS.n648 VSS.t38 9.84898
R2301 VSS.n656 VSS.n206 9.84898
R2302 VSS.n711 VSS.n184 9.05973
R2303 VSS.t72 VSS.n751 9.05973
R2304 VSS.t70 VSS.t72 9.05973
R2305 VSS.t24 VSS.t70 9.05973
R2306 VSS.t22 VSS.t24 9.05973
R2307 VSS.t362 VSS.t184 9.05973
R2308 VSS.t229 VSS.t362 9.05973
R2309 VSS.t231 VSS.t229 9.05973
R2310 VSS.t209 VSS.t199 9.05973
R2311 VSS.t199 VSS.t354 9.05973
R2312 VSS.t354 VSS.t197 9.05973
R2313 VSS.t303 VSS.t301 9.05973
R2314 VSS.t57 VSS.t47 9.05973
R2315 VSS.t47 VSS.t46 9.05973
R2316 VSS.t46 VSS.t20 9.05973
R2317 VSS.t20 VSS.t19 9.05973
R2318 VSS.t19 VSS.t187 9.05973
R2319 VSS.t187 VSS.t186 9.05973
R2320 VSS.t186 VSS.t8 9.05973
R2321 VSS.t8 VSS.t7 9.05973
R2322 VSS.t7 VSS.t61 9.05973
R2323 VSS.t61 VSS.t60 9.05973
R2324 VSS.t60 VSS.t48 9.05973
R2325 VSS.t244 VSS.t243 9.05973
R2326 VSS.t244 VSS.t245 9.05973
R2327 VSS.t246 VSS.t245 9.05973
R2328 VSS.t247 VSS.t246 9.05973
R2329 VSS.t248 VSS.t247 9.05973
R2330 VSS.t249 VSS.t248 9.05973
R2331 VSS.t250 VSS.t249 9.05973
R2332 VSS.t220 VSS.t218 9.05973
R2333 VSS.t222 VSS.t220 9.05973
R2334 VSS.t224 VSS.t222 9.05973
R2335 VSS.t226 VSS.t224 9.05973
R2336 VSS.t87 VSS.t88 9.05973
R2337 VSS.t88 VSS.t89 9.05973
R2338 VSS.t89 VSS.t90 9.05973
R2339 VSS.t90 VSS.t91 9.05973
R2340 VSS.t91 VSS.t92 9.05973
R2341 VSS.t93 VSS.t92 9.05973
R2342 VSS.t94 VSS.t93 9.05973
R2343 VSS.t333 VSS.t323 9.05973
R2344 VSS.t335 VSS.t333 9.05973
R2345 VSS.t337 VSS.t335 9.05973
R2346 VSS.t5 VSS.t337 9.05973
R2347 VSS.t58 VSS.t5 9.05973
R2348 VSS.t341 VSS.t58 9.05973
R2349 VSS.t343 VSS.t341 9.05973
R2350 VSS.t345 VSS.t343 9.05973
R2351 VSS.t347 VSS.t345 9.05973
R2352 VSS.t349 VSS.t347 9.05973
R2353 VSS.t351 VSS.t349 9.05973
R2354 VSS.n144 VSS.t351 9.05973
R2355 VSS.t269 VSS.t366 9.05973
R2356 VSS.t207 VSS.t269 9.05973
R2357 VSS.t358 VSS.t207 9.05973
R2358 VSS.t75 VSS.t205 9.05973
R2359 VSS.t205 VSS.t271 9.05973
R2360 VSS.t271 VSS.t360 9.05973
R2361 VSS.t293 VSS.t291 9.05973
R2362 VSS.t291 VSS.t264 9.05973
R2363 VSS.t264 VSS.t262 9.05973
R2364 VSS.n151 VSS.t262 9.05973
R2365 VSS.n463 VSS.n212 8.20757
R2366 VSS.n348 VSS.n251 7.91354
R2367 VSS.n323 VSS.n322 7.8912
R2368 VSS.n759 VSS.t57 6.79493
R2369 VSS.t48 VSS.n100 6.79493
R2370 VSS.t306 VSS.n87 6.79493
R2371 VSS.t305 VSS.t307 6.79493
R2372 VSS.t217 VSS.t309 6.79493
R2373 VSS.t216 VSS.t311 6.79493
R2374 VSS.t1 VSS.t313 6.79493
R2375 VSS.t0 VSS.t315 6.79493
R2376 VSS.t54 VSS.t317 6.79493
R2377 VSS.t53 VSS.t319 6.79493
R2378 VSS.t45 VSS.t321 6.79493
R2379 VSS.t44 VSS.t325 6.79493
R2380 VSS.t16 VSS.t327 6.79493
R2381 VSS.t15 VSS.t329 6.79493
R2382 VSS.n661 VSS.t109 6.57557
R2383 VSS.n629 VSS.t258 6.56616
R2384 VSS.n629 VSS.t287 6.56616
R2385 VSS.n635 VSS.t145 6.56616
R2386 VSS.n635 VSS.t147 6.56616
R2387 VSS.n641 VSS.t275 6.56616
R2388 VSS.n360 VSS.t191 6.56616
R2389 VSS.t42 VSS.n359 6.56616
R2390 VSS.n359 VSS.t13 6.56616
R2391 VSS.n333 VSS.n331 6.49615
R2392 VSS.n693 VSS.t112 6.45713
R2393 VSS.n692 VSS.n691 6.41078
R2394 VSS.n333 VSS.n332 6.31615
R2395 VSS.n661 VSS.n660 6.29483
R2396 VSS.n692 VSS.n690 6.29483
R2397 VSS.n663 VSS.n662 6.29333
R2398 VSS.n334 VSS.n333 6.278
R2399 VSS.n283 VSS.n281 6.21789
R2400 VSS.n557 VSS.t276 5.78141
R2401 VSS.n14 VSS.t227 5.78141
R2402 VSS.n556 VSS.n554 5.66497
R2403 VSS.n521 VSS.n519 5.66497
R2404 VSS.n572 VSS.n570 5.66497
R2405 VSS.n45 VSS.n43 5.66497
R2406 VSS.n55 VSS.n53 5.66497
R2407 VSS.n13 VSS.n11 5.66497
R2408 VSS.n664 VSS.n663 5.6555
R2409 VSS.n346 VSS.t32 5.65267
R2410 VSS.t369 VSS.t228 5.65267
R2411 VSS.n694 VSS.n693 5.5955
R2412 VSS.n537 VSS.n535 5.57485
R2413 VSS.n542 VSS.n540 5.57485
R2414 VSS.n583 VSS.n581 5.57485
R2415 VSS.n596 VSS.n594 5.57485
R2416 VSS.n6 VSS.n5 5.57485
R2417 VSS.n76 VSS.n74 5.57485
R2418 VSS.n26 VSS.n24 5.57485
R2419 VSS.n21 VSS.n20 5.57485
R2420 VSS.n556 VSS.n555 5.4755
R2421 VSS.n521 VSS.n520 5.4755
R2422 VSS.n523 VSS.n522 5.4755
R2423 VSS.n525 VSS.n524 5.4755
R2424 VSS.n527 VSS.n526 5.4755
R2425 VSS.n529 VSS.n528 5.4755
R2426 VSS.n567 VSS.n530 5.4755
R2427 VSS.n569 VSS.n568 5.4755
R2428 VSS.n576 VSS.n575 5.4755
R2429 VSS.n574 VSS.n573 5.4755
R2430 VSS.n572 VSS.n571 5.4755
R2431 VSS.n45 VSS.n44 5.4755
R2432 VSS.n47 VSS.n46 5.4755
R2433 VSS.n49 VSS.n48 5.4755
R2434 VSS.n52 VSS.n51 5.4755
R2435 VSS.n65 VSS.n64 5.4755
R2436 VSS.n63 VSS.n62 5.4755
R2437 VSS.n61 VSS.n60 5.4755
R2438 VSS.n59 VSS.n58 5.4755
R2439 VSS.n57 VSS.n56 5.4755
R2440 VSS.n55 VSS.n54 5.4755
R2441 VSS.n13 VSS.n12 5.4755
R2442 VSS.n537 VSS.n536 5.38537
R2443 VSS.n542 VSS.n541 5.38537
R2444 VSS.n544 VSS.n543 5.38537
R2445 VSS.n546 VSS.n545 5.38537
R2446 VSS.n583 VSS.n582 5.38537
R2447 VSS.n587 VSS.n584 5.38537
R2448 VSS.n586 VSS.n585 5.38537
R2449 VSS.n596 VSS.n595 5.38537
R2450 VSS.n6 VSS.n4 5.38537
R2451 VSS.n80 VSS.n79 5.38537
R2452 VSS.n78 VSS.n77 5.38537
R2453 VSS.n76 VSS.n75 5.38537
R2454 VSS.n30 VSS.n29 5.38537
R2455 VSS.n28 VSS.n27 5.38537
R2456 VSS.n26 VSS.n25 5.38537
R2457 VSS.n21 VSS.n19 5.38537
R2458 VSS.n393 VSS.n392 5.2005
R2459 VSS.n395 VSS.n394 5.2005
R2460 VSS.n397 VSS.n396 5.2005
R2461 VSS.n398 VSS.n382 5.2005
R2462 VSS.n408 VSS.n407 5.2005
R2463 VSS.n407 VSS.n406 5.2005
R2464 VSS.n383 VSS.n381 5.2005
R2465 VSS.n405 VSS.n383 5.2005
R2466 VSS.n403 VSS.n402 5.2005
R2467 VSS.n404 VSS.n403 5.2005
R2468 VSS.n247 VSS.n245 5.2005
R2469 VSS.n399 VSS.n245 5.2005
R2470 VSS.n465 VSS.n464 5.2005
R2471 VSS.n465 VSS.n246 5.2005
R2472 VSS.n466 VSS.n235 5.2005
R2473 VSS.n466 VSS.n244 5.2005
R2474 VSS.n360 VSS.n241 5.2005
R2475 VSS.n243 VSS.n241 5.2005
R2476 VSS.n488 VSS.n487 5.2005
R2477 VSS.n487 VSS.n486 5.2005
R2478 VSS.n485 VSS.n242 5.2005
R2479 VSS.n484 VSS.n483 5.2005
R2480 VSS.n482 VSS.n481 5.2005
R2481 VSS.n480 VSS.n479 5.2005
R2482 VSS.n478 VSS.n477 5.2005
R2483 VSS.n476 VSS.n475 5.2005
R2484 VSS.n474 VSS.n473 5.2005
R2485 VSS.n472 VSS.n471 5.2005
R2486 VSS.n470 VSS.n469 5.2005
R2487 VSS.n468 VSS.n467 5.2005
R2488 VSS.n445 VSS.n444 5.2005
R2489 VSS.n447 VSS.n365 5.2005
R2490 VSS.n450 VSS.n449 5.2005
R2491 VSS.n451 VSS.n364 5.2005
R2492 VSS.n453 VSS.n452 5.2005
R2493 VSS.n455 VSS.n363 5.2005
R2494 VSS.n456 VSS.n206 5.2005
R2495 VSS.n457 VSS.n456 5.2005
R2496 VSS.n248 VSS.n212 5.2005
R2497 VSS.n458 VSS.n248 5.2005
R2498 VSS.n462 VSS.n461 5.2005
R2499 VSS.n461 VSS.n460 5.2005
R2500 VSS.n362 VSS.n361 5.2005
R2501 VSS.n459 VSS.n362 5.2005
R2502 VSS.n410 VSS.n377 5.2005
R2503 VSS.n377 VSS.n376 5.2005
R2504 VSS.n414 VSS.n413 5.2005
R2505 VSS.n415 VSS.n414 5.2005
R2506 VSS.t121 VSS.n375 5.2005
R2507 VSS.n416 VSS.n375 5.2005
R2508 VSS.n419 VSS.n418 5.2005
R2509 VSS.n418 VSS.n417 5.2005
R2510 VSS.n422 VSS.n373 5.2005
R2511 VSS.n373 VSS.n372 5.2005
R2512 VSS.n427 VSS.t286 5.2005
R2513 VSS.n428 VSS.n427 5.2005
R2514 VSS.n424 VSS.n370 5.2005
R2515 VSS.n429 VSS.n370 5.2005
R2516 VSS.n432 VSS.n431 5.2005
R2517 VSS.n431 VSS.n430 5.2005
R2518 VSS.t122 VSS.n368 5.2005
R2519 VSS.n371 VSS.n368 5.2005
R2520 VSS.n436 VSS.n435 5.2005
R2521 VSS.n436 VSS.n367 5.2005
R2522 VSS.n441 VSS.n440 5.2005
R2523 VSS.n442 VSS.n441 5.2005
R2524 VSS.n443 VSS.n366 5.2005
R2525 VSS.n687 VSS.n686 5.2005
R2526 VSS.n687 VSS.n189 5.2005
R2527 VSS.n197 VSS.n190 5.2005
R2528 VSS.n684 VSS.n683 5.2005
R2529 VSS.n682 VSS.n196 5.2005
R2530 VSS.n681 VSS.n680 5.2005
R2531 VSS.n679 VSS.n678 5.2005
R2532 VSS.n677 VSS.n676 5.2005
R2533 VSS.n675 VSS.n674 5.2005
R2534 VSS.n673 VSS.n672 5.2005
R2535 VSS.n156 VSS.n115 5.2005
R2536 VSS.n156 VSS.n155 5.2005
R2537 VSS.n125 VSS.n122 5.2005
R2538 VSS.n154 VSS.n122 5.2005
R2539 VSS.n152 VSS.n151 5.2005
R2540 VSS.n153 VSS.n152 5.2005
R2541 VSS.n131 VSS.n124 5.2005
R2542 VSS.n124 VSS.n123 5.2005
R2543 VSS.n145 VSS.n132 5.2005
R2544 VSS.n135 VSS.n132 5.2005
R2545 VSS.n144 VSS.n133 5.2005
R2546 VSS.n136 VSS.n133 5.2005
R2547 VSS.n143 VSS.n140 5.2005
R2548 VSS.n140 VSS.n139 5.2005
R2549 VSS.n134 VSS.n87 5.2005
R2550 VSS.n138 VSS.n134 5.2005
R2551 VSS.t93 VSS.n88 5.2005
R2552 VSS.n137 VSS.n88 5.2005
R2553 VSS.n95 VSS.n94 5.2005
R2554 VSS.n97 VSS.n95 5.2005
R2555 VSS.t244 VSS.n764 5.2005
R2556 VSS.n764 VSS.n763 5.2005
R2557 VSS.n100 VSS.n96 5.2005
R2558 VSS.n762 VSS.n96 5.2005
R2559 VSS.n760 VSS.n759 5.2005
R2560 VSS.n761 VSS.n760 5.2005
R2561 VSS.n104 VSS.n99 5.2005
R2562 VSS.n99 VSS.n98 5.2005
R2563 VSS.n753 VSS.n105 5.2005
R2564 VSS.n720 VSS.n105 5.2005
R2565 VSS.n752 VSS.n106 5.2005
R2566 VSS.n721 VSS.n106 5.2005
R2567 VSS.n751 VSS.n107 5.2005
R2568 VSS.n722 VSS.n107 5.2005
R2569 VSS.n723 VSS.n108 5.2005
R2570 VSS.n724 VSS.n723 5.2005
R2571 VSS.n745 VSS.n112 5.2005
R2572 VSS.n725 VSS.n112 5.2005
R2573 VSS.n744 VSS.n111 5.2005
R2574 VSS.n111 VSS.n110 5.2005
R2575 VSS.n719 VSS.n717 5.2005
R2576 VSS.n742 VSS.n741 5.2005
R2577 VSS.n740 VSS.n718 5.2005
R2578 VSS.n739 VSS.n738 5.2005
R2579 VSS.n737 VSS.n736 5.2005
R2580 VSS.n735 VSS.n734 5.2005
R2581 VSS.n733 VSS.n732 5.2005
R2582 VSS.n731 VSS.n730 5.2005
R2583 VSS.n729 VSS.n728 5.2005
R2584 VSS.n727 VSS.n726 5.2005
R2585 VSS.n158 VSS.n157 5.2005
R2586 VSS.n160 VSS.n159 5.2005
R2587 VSS.n162 VSS.n161 5.2005
R2588 VSS.n164 VSS.n163 5.2005
R2589 VSS.n166 VSS.n165 5.2005
R2590 VSS.n168 VSS.n167 5.2005
R2591 VSS.n170 VSS.n169 5.2005
R2592 VSS.n172 VSS.n171 5.2005
R2593 VSS.n178 VSS.n118 5.2005
R2594 VSS.n173 VSS.n118 5.2005
R2595 VSS.n174 VSS.n119 5.2005
R2596 VSS.n176 VSS.n175 5.2005
R2597 VSS.n120 VSS.n115 5.2005
R2598 VSS.n121 VSS.n120 5.2005
R2599 VSS.n126 VSS.n125 5.2005
R2600 VSS.n128 VSS.n126 5.2005
R2601 VSS.n151 VSS.n150 5.2005
R2602 VSS.n150 VSS.n149 5.2005
R2603 VSS.n131 VSS.n127 5.2005
R2604 VSS.n148 VSS.n127 5.2005
R2605 VSS.n146 VSS.n145 5.2005
R2606 VSS.n147 VSS.n146 5.2005
R2607 VSS.n144 VSS.n130 5.2005
R2608 VSS.n130 VSS.n129 5.2005
R2609 VSS.n143 VSS.n142 5.2005
R2610 VSS.n142 VSS.n141 5.2005
R2611 VSS.n89 VSS.n87 5.2005
R2612 VSS.n91 VSS.n89 5.2005
R2613 VSS.t93 VSS.n769 5.2005
R2614 VSS.n769 VSS.n768 5.2005
R2615 VSS.n94 VSS.n90 5.2005
R2616 VSS.n767 VSS.n90 5.2005
R2617 VSS.n765 VSS.t244 5.2005
R2618 VSS.n766 VSS.n765 5.2005
R2619 VSS.n100 VSS.n93 5.2005
R2620 VSS.n93 VSS.n92 5.2005
R2621 VSS.n759 VSS.n758 5.2005
R2622 VSS.n758 VSS.n757 5.2005
R2623 VSS.n104 VSS.n101 5.2005
R2624 VSS.n756 VSS.n101 5.2005
R2625 VSS.n754 VSS.n753 5.2005
R2626 VSS.n755 VSS.n754 5.2005
R2627 VSS.n752 VSS.n103 5.2005
R2628 VSS.n103 VSS.n102 5.2005
R2629 VSS.n751 VSS.n750 5.2005
R2630 VSS.n750 VSS.n749 5.2005
R2631 VSS.n109 VSS.n108 5.2005
R2632 VSS.n748 VSS.n109 5.2005
R2633 VSS.n746 VSS.n745 5.2005
R2634 VSS.n747 VSS.n746 5.2005
R2635 VSS.n689 VSS.n688 5.2005
R2636 VSS.n696 VSS.n695 5.2005
R2637 VSS.n698 VSS.n697 5.2005
R2638 VSS.n700 VSS.n699 5.2005
R2639 VSS.n711 VSS.n181 5.2005
R2640 VSS.n701 VSS.n181 5.2005
R2641 VSS.n703 VSS.n702 5.2005
R2642 VSS.n705 VSS.n704 5.2005
R2643 VSS.n711 VSS.n185 5.2005
R2644 VSS.n706 VSS.n185 5.2005
R2645 VSS.n707 VSS.n186 5.2005
R2646 VSS.n709 VSS.n708 5.2005
R2647 VSS.n348 VSS.n213 5.2005
R2648 VSS.n215 VSS.n213 5.2005
R2649 VSS.n320 VSS.n319 5.2005
R2650 VSS.n319 VSS.n318 5.2005
R2651 VSS.n294 VSS.n257 5.2005
R2652 VSS.n317 VSS.n257 5.2005
R2653 VSS.n295 VSS.n294 5.2005
R2654 VSS.n295 VSS.n267 5.2005
R2655 VSS.n320 VSS.n250 5.2005
R2656 VSS.n250 VSS.n249 5.2005
R2657 VSS.n349 VSS.n348 5.2005
R2658 VSS.n350 VSS.n349 5.2005
R2659 VSS.n297 VSS.n296 5.2005
R2660 VSS.n299 VSS.n298 5.2005
R2661 VSS.n301 VSS.n300 5.2005
R2662 VSS.n303 VSS.n302 5.2005
R2663 VSS.n305 VSS.n304 5.2005
R2664 VSS.n307 VSS.n306 5.2005
R2665 VSS.n309 VSS.n308 5.2005
R2666 VSS.n310 VSS.n266 5.2005
R2667 VSS.n313 VSS.n312 5.2005
R2668 VSS.n312 VSS.n311 5.2005
R2669 VSS.n259 VSS.n258 5.2005
R2670 VSS.n316 VSS.n315 5.2005
R2671 VSS.n273 VSS.n187 5.2005
R2672 VSS.n188 VSS.n187 5.2005
R2673 VSS.n276 VSS.n275 5.2005
R2674 VSS.n277 VSS.n276 5.2005
R2675 VSS.n272 VSS.t78 5.2005
R2676 VSS.n278 VSS.n272 5.2005
R2677 VSS.n281 VSS.n280 5.2005
R2678 VSS.n280 VSS.n279 5.2005
R2679 VSS.n285 VSS.n270 5.2005
R2680 VSS.n270 VSS.n269 5.2005
R2681 VSS.n288 VSS.n287 5.2005
R2682 VSS.n289 VSS.n288 5.2005
R2683 VSS.n268 VSS.n260 5.2005
R2684 VSS.n290 VSS.n268 5.2005
R2685 VSS.n293 VSS.n292 5.2005
R2686 VSS.n292 VSS.n291 5.2005
R2687 VSS.t251 VSS.n255 5.2005
R2688 VSS.n255 VSS.n254 5.2005
R2689 VSS.n324 VSS.n323 5.2005
R2690 VSS.n325 VSS.n324 5.2005
R2691 VSS.n321 VSS.n252 5.2005
R2692 VSS.n326 VSS.n252 5.2005
R2693 VSS.n346 VSS.n345 5.2005
R2694 VSS.n345 VSS.n344 5.2005
R2695 VSS.n622 VSS.n621 5.2005
R2696 VSS.n623 VSS.n622 5.2005
R2697 VSS.n495 VSS.n494 5.2005
R2698 VSS.n624 VSS.n495 5.2005
R2699 VSS.n627 VSS.n626 5.2005
R2700 VSS.n626 VSS.n625 5.2005
R2701 VSS.n628 VSS.n234 5.2005
R2702 VSS.n234 VSS.n233 5.2005
R2703 VSS.n630 VSS.n629 5.2005
R2704 VSS.n631 VSS.n630 5.2005
R2705 VSS.n489 VSS.n231 5.2005
R2706 VSS.n632 VSS.n231 5.2005
R2707 VSS.n635 VSS.n634 5.2005
R2708 VSS.n634 VSS.n633 5.2005
R2709 VSS.n512 VSS.n230 5.2005
R2710 VSS.n232 VSS.n230 5.2005
R2711 VSS.t236 VSS.n224 5.2005
R2712 VSS.n224 VSS.n223 5.2005
R2713 VSS.n642 VSS.n641 5.2005
R2714 VSS.n643 VSS.n642 5.2005
R2715 VSS.t85 VSS.n222 5.2005
R2716 VSS.n644 VSS.n222 5.2005
R2717 VSS.n647 VSS.n646 5.2005
R2718 VSS.n646 VSS.n645 5.2005
R2719 VSS.n648 VSS.n217 5.2005
R2720 VSS.n217 VSS.n216 5.2005
R2721 VSS.n650 VSS.n649 5.2005
R2722 VSS.n651 VSS.n650 5.2005
R2723 VSS.n359 VSS.n214 5.2005
R2724 VSS.n652 VSS.n214 5.2005
R2725 VSS.n655 VSS.n654 5.2005
R2726 VSS.n654 VSS.n653 5.2005
R2727 VSS.n655 VSS.n211 5.2005
R2728 VSS.n351 VSS.n211 5.2005
R2729 VSS.n359 VSS.n358 5.2005
R2730 VSS.n358 VSS.n357 5.2005
R2731 VSS.n649 VSS.n218 5.2005
R2732 VSS.n356 VSS.n218 5.2005
R2733 VSS.n648 VSS.n219 5.2005
R2734 VSS.n355 VSS.n219 5.2005
R2735 VSS.n647 VSS.n220 5.2005
R2736 VSS.n354 VSS.n220 5.2005
R2737 VSS.n352 VSS.t85 5.2005
R2738 VSS.n353 VSS.n352 5.2005
R2739 VSS.n641 VSS.n225 5.2005
R2740 VSS.n227 VSS.n225 5.2005
R2741 VSS.t236 VSS.n640 5.2005
R2742 VSS.n640 VSS.n639 5.2005
R2743 VSS.n512 VSS.n226 5.2005
R2744 VSS.n638 VSS.n226 5.2005
R2745 VSS.n636 VSS.n635 5.2005
R2746 VSS.n637 VSS.n636 5.2005
R2747 VSS.n489 VSS.n229 5.2005
R2748 VSS.n229 VSS.n228 5.2005
R2749 VSS.n629 VSS.n491 5.2005
R2750 VSS.n506 VSS.n491 5.2005
R2751 VSS.n628 VSS.n492 5.2005
R2752 VSS.n507 VSS.n492 5.2005
R2753 VSS.n627 VSS.n493 5.2005
R2754 VSS.n508 VSS.n493 5.2005
R2755 VSS.n509 VSS.n494 5.2005
R2756 VSS.n510 VSS.n509 5.2005
R2757 VSS.n621 VSS.n498 5.2005
R2758 VSS.n511 VSS.n498 5.2005
R2759 VSS.n620 VSS.n497 5.2005
R2760 VSS.n497 VSS.n496 5.2005
R2761 VSS.n505 VSS.n503 5.2005
R2762 VSS.n618 VSS.n617 5.2005
R2763 VSS.n616 VSS.n504 5.2005
R2764 VSS.n615 VSS.n614 5.2005
R2765 VSS.n613 VSS.n612 5.2005
R2766 VSS.n611 VSS.n610 5.2005
R2767 VSS.n609 VSS.n608 5.2005
R2768 VSS.n607 VSS.n606 5.2005
R2769 VSS.n605 VSS.n604 5.2005
R2770 VSS.n603 VSS.n602 5.2005
R2771 VSS.n343 VSS.n253 5.2005
R2772 VSS.n342 VSS.n341 5.2005
R2773 VSS.n340 VSS.n339 5.2005
R2774 VSS.n338 VSS.n337 5.2005
R2775 VSS.n336 VSS.n335 5.2005
R2776 VSS.n330 VSS.n329 5.2005
R2777 VSS.n328 VSS.n327 5.2005
R2778 VSS.n205 VSS.n204 5.2005
R2779 VSS.n659 VSS.n658 5.2005
R2780 VSS.n665 VSS.n201 5.2005
R2781 VSS.n671 VSS.n670 5.2005
R2782 VSS.n671 VSS.n198 5.2005
R2783 VSS.n202 VSS.n199 5.2005
R2784 VSS.n668 VSS.n667 5.2005
R2785 VSS.n390 VSS.n389 4.7005
R2786 VSS.n743 VSS.n717 4.6486
R2787 VSS.n718 VSS.n716 4.6486
R2788 VSS.n737 VSS.n715 4.6486
R2789 VSS.n733 VSS.n714 4.6486
R2790 VSS.n729 VSS.n713 4.6486
R2791 VSS.n157 VSS.n114 4.6486
R2792 VSS.n164 VSS.n116 4.6486
R2793 VSS.n165 VSS.n113 4.6486
R2794 VSS.n171 VSS.n117 4.6486
R2795 VSS.n299 VSS.n263 4.6486
R2796 VSS.n303 VSS.n264 4.6486
R2797 VSS.n304 VSS.n261 4.6486
R2798 VSS.n266 VSS.n265 4.6486
R2799 VSS.n619 VSS.n503 4.6486
R2800 VSS.n504 VSS.n502 4.6486
R2801 VSS.n613 VSS.n501 4.6486
R2802 VSS.n609 VSS.n500 4.6486
R2803 VSS.n605 VSS.n499 4.6486
R2804 VSS.n602 VSS.n499 4.6486
R2805 VSS.n606 VSS.n500 4.6486
R2806 VSS.n610 VSS.n501 4.6486
R2807 VSS.n614 VSS.n502 4.6486
R2808 VSS.n619 VSS.n618 4.6486
R2809 VSS.n296 VSS.n263 4.6486
R2810 VSS.n300 VSS.n264 4.6486
R2811 VSS.n307 VSS.n261 4.6486
R2812 VSS.n308 VSS.n265 4.6486
R2813 VSS.n160 VSS.n114 4.6486
R2814 VSS.n161 VSS.n116 4.6486
R2815 VSS.n168 VSS.n113 4.6486
R2816 VSS.n169 VSS.n117 4.6486
R2817 VSS.n726 VSS.n713 4.6486
R2818 VSS.n730 VSS.n714 4.6486
R2819 VSS.n734 VSS.n715 4.6486
R2820 VSS.n738 VSS.n716 4.6486
R2821 VSS.n743 VSS.n742 4.6486
R2822 VSS.n753 VSS.t231 4.53012
R2823 VSS.n753 VSS.t209 4.53012
R2824 VSS.n94 VSS.t226 4.53012
R2825 VSS.n143 VSS.t331 4.53012
R2826 VSS.t323 VSS.n143 4.53012
R2827 VSS.n145 VSS.t358 4.53012
R2828 VSS.n145 VSS.t75 4.53012
R2829 VSS.n598 VSS.n515 4.5005
R2830 VSS.n593 VSS.n592 4.5005
R2831 VSS.n591 VSS.n516 4.5005
R2832 VSS.n590 VSS.n589 4.5005
R2833 VSS.n518 VSS.n517 4.5005
R2834 VSS.n563 VSS.n562 4.5005
R2835 VSS.n561 VSS.n531 4.5005
R2836 VSS.n560 VSS.n559 4.5005
R2837 VSS.n553 VSS.n532 4.5005
R2838 VSS.n552 VSS.n551 4.5005
R2839 VSS.n550 VSS.n549 4.5005
R2840 VSS.n34 VSS.n33 4.5005
R2841 VSS.n36 VSS.n35 4.5005
R2842 VSS.n37 VSS.n16 4.5005
R2843 VSS.n39 VSS.n38 4.5005
R2844 VSS.n41 VSS.n40 4.5005
R2845 VSS.n42 VSS.n9 4.5005
R2846 VSS.n70 VSS.n69 4.5005
R2847 VSS.n72 VSS.n71 4.5005
R2848 VSS.n82 VSS.n3 4.5005
R2849 VSS.n84 VSS.n83 4.5005
R2850 VSS.n85 VSS.n1 4.5005
R2851 VSS.n421 VSS.n420 4.48215
R2852 VSS.n426 VSS.n425 4.48215
R2853 VSS.n423 VSS.n369 4.48215
R2854 VSS.n434 VSS.n433 4.48215
R2855 VSS.n439 VSS.n438 4.48215
R2856 VSS.n600 VSS.n514 4.47524
R2857 VSS.n772 VSS.n771 4.47524
R2858 VSS.n392 VSS.n379 4.34122
R2859 VSS.n396 VSS.n380 4.34122
R2860 VSS.n242 VSS.n240 4.34122
R2861 VSS.n482 VSS.n239 4.34122
R2862 VSS.n478 VSS.n238 4.34122
R2863 VSS.n474 VSS.n237 4.34122
R2864 VSS.n470 VSS.n236 4.34122
R2865 VSS.n446 VSS.n445 4.34122
R2866 VSS.n449 VSS.n448 4.34122
R2867 VSS.n454 VSS.n453 4.34122
R2868 VSS.n382 VSS.n380 4.34122
R2869 VSS.n395 VSS.n379 4.34122
R2870 VSS.n467 VSS.n236 4.34122
R2871 VSS.n471 VSS.n237 4.34122
R2872 VSS.n475 VSS.n238 4.34122
R2873 VSS.n479 VSS.n239 4.34122
R2874 VSS.n483 VSS.n240 4.34122
R2875 VSS.n455 VSS.n454 4.34122
R2876 VSS.n448 VSS.n364 4.34122
R2877 VSS.n447 VSS.n446 4.34122
R2878 VSS.n685 VSS.n190 4.34122
R2879 VSS.n196 VSS.n195 4.34122
R2880 VSS.n679 VSS.n194 4.34122
R2881 VSS.n675 VSS.n193 4.34122
R2882 VSS.n696 VSS.n183 4.34122
R2883 VSS.n699 VSS.n182 4.34122
R2884 VSS.n702 VSS.n180 4.34122
R2885 VSS.n710 VSS.n186 4.34122
R2886 VSS.n253 VSS.n207 4.34122
R2887 VSS.n340 VSS.n208 4.34122
R2888 VSS.n336 VSS.n209 4.34122
R2889 VSS.n328 VSS.n210 4.34122
R2890 VSS.n658 VSS.n657 4.34122
R2891 VSS.n669 VSS.n199 4.34122
R2892 VSS.n669 VSS.n668 4.34122
R2893 VSS.n672 VSS.n193 4.34122
R2894 VSS.n676 VSS.n194 4.34122
R2895 VSS.n680 VSS.n195 4.34122
R2896 VSS.n685 VSS.n684 4.34122
R2897 VSS.n657 VSS.n201 4.34122
R2898 VSS.n210 VSS.n205 4.34122
R2899 VSS.n329 VSS.n209 4.34122
R2900 VSS.n337 VSS.n208 4.34122
R2901 VSS.n341 VSS.n207 4.34122
R2902 VSS.n688 VSS.n183 4.34122
R2903 VSS.n697 VSS.n182 4.34122
R2904 VSS.n704 VSS.n180 4.34122
R2905 VSS.n710 VSS.n709 4.34122
R2906 VSS.n490 VSS.n489 4.10404
R2907 VSS.n347 VSS.n251 4.08867
R2908 VSS.n390 VSS.n0 3.803
R2909 VSS.n177 VSS.n119 3.72542
R2910 VSS.n314 VSS.n259 3.72542
R2911 VSS.n315 VSS.n314 3.72542
R2912 VSS.n177 VSS.n176 3.72542
R2913 VSS.n412 VSS.n411 3.6553
R2914 VSS.n378 VSS.n374 3.6553
R2915 VSS.n284 VSS.n283 3.63551
R2916 VSS.n347 VSS.t30 3.3918
R2917 VSS.t202 VSS.t147 3.28333
R2918 VSS.t63 VSS.t149 3.28333
R2919 VSS.t62 VSS.t151 3.28333
R2920 VSS.t52 VSS.t153 3.28333
R2921 VSS.t51 VSS.t155 3.28333
R2922 VSS.t35 VSS.t157 3.28333
R2923 VSS.t34 VSS.t159 3.28333
R2924 VSS.t181 VSS.t161 3.28333
R2925 VSS.t180 VSS.t163 3.28333
R2926 VSS.t215 VSS.t165 3.28333
R2927 VSS.t214 VSS.t167 3.28333
R2928 VSS.t183 VSS.t169 3.28333
R2929 VSS.n361 VSS.t175 3.28333
R2930 VSS.n462 VSS.t119 3.28333
R2931 VSS.n203 VSS.n0 2.62175
R2932 VSS.n599 VSS.n203 2.31862
R2933 VSS.t307 VSS.t306 2.26531
R2934 VSS.t309 VSS.t305 2.26531
R2935 VSS.t311 VSS.t217 2.26531
R2936 VSS.t313 VSS.t216 2.26531
R2937 VSS.t315 VSS.t1 2.26531
R2938 VSS.t317 VSS.t0 2.26531
R2939 VSS.t319 VSS.t54 2.26531
R2940 VSS.t321 VSS.t53 2.26531
R2941 VSS.t325 VSS.t45 2.26531
R2942 VSS.t327 VSS.t44 2.26531
R2943 VSS.t329 VSS.t16 2.26531
R2944 VSS.t331 VSS.t15 2.26531
R2945 VSS.n600 VSS.n599 2.25898
R2946 VSS.n773 VSS.n772 2.25898
R2947 VSS.n34 VSS.n22 1.73954
R2948 VSS.n550 VSS.n538 1.73942
R2949 VSS.n511 VSS.n510 1.1255
R2950 VSS.n510 VSS.n508 1.1255
R2951 VSS.n508 VSS.n507 1.1255
R2952 VSS.n507 VSS.n506 1.1255
R2953 VSS.n506 VSS.n228 1.1255
R2954 VSS.n637 VSS.n228 1.1255
R2955 VSS.n638 VSS.n637 1.1255
R2956 VSS.n639 VSS.n638 1.1255
R2957 VSS.n639 VSS.n227 1.1255
R2958 VSS.n353 VSS.n227 1.1255
R2959 VSS.n354 VSS.n353 1.1255
R2960 VSS.n355 VSS.n354 1.1255
R2961 VSS.n356 VSS.n355 1.1255
R2962 VSS.n357 VSS.n356 1.1255
R2963 VSS.n357 VSS.n351 1.1255
R2964 VSS.n351 VSS.n350 1.1255
R2965 VSS.n350 VSS.n249 1.1255
R2966 VSS.n267 VSS.n249 1.1255
R2967 VSS.n298 VSS.n297 1.1255
R2968 VSS.n301 VSS.n298 1.1255
R2969 VSS.n302 VSS.n301 1.1255
R2970 VSS.n305 VSS.n302 1.1255
R2971 VSS.n306 VSS.n305 1.1255
R2972 VSS.n309 VSS.n306 1.1255
R2973 VSS.n310 VSS.n309 1.1255
R2974 VSS.n311 VSS.n310 1.1255
R2975 VSS.n311 VSS.n258 1.1255
R2976 VSS.n624 VSS.n623 1.1255
R2977 VSS.n625 VSS.n624 1.1255
R2978 VSS.n625 VSS.n233 1.1255
R2979 VSS.n631 VSS.n233 1.1255
R2980 VSS.n632 VSS.n631 1.1255
R2981 VSS.n633 VSS.n632 1.1255
R2982 VSS.n633 VSS.n232 1.1255
R2983 VSS.n232 VSS.n223 1.1255
R2984 VSS.n643 VSS.n223 1.1255
R2985 VSS.n644 VSS.n643 1.1255
R2986 VSS.n645 VSS.n644 1.1255
R2987 VSS.n645 VSS.n216 1.1255
R2988 VSS.n651 VSS.n216 1.1255
R2989 VSS.n652 VSS.n651 1.1255
R2990 VSS.n653 VSS.n652 1.1255
R2991 VSS.n653 VSS.n215 1.1255
R2992 VSS.n318 VSS.n215 1.1255
R2993 VSS.n318 VSS.n317 1.1255
R2994 VSS.n604 VSS.n603 1.1255
R2995 VSS.n607 VSS.n604 1.1255
R2996 VSS.n608 VSS.n607 1.1255
R2997 VSS.n611 VSS.n608 1.1255
R2998 VSS.n612 VSS.n611 1.1255
R2999 VSS.n615 VSS.n612 1.1255
R3000 VSS.n616 VSS.n615 1.1255
R3001 VSS.n617 VSS.n616 1.1255
R3002 VSS.n617 VSS.n505 1.1255
R3003 VSS.n725 VSS.n724 1.1255
R3004 VSS.n724 VSS.n722 1.1255
R3005 VSS.n722 VSS.n721 1.1255
R3006 VSS.n721 VSS.n720 1.1255
R3007 VSS.n720 VSS.n98 1.1255
R3008 VSS.n761 VSS.n98 1.1255
R3009 VSS.n762 VSS.n761 1.1255
R3010 VSS.n763 VSS.n762 1.1255
R3011 VSS.n763 VSS.n97 1.1255
R3012 VSS.n137 VSS.n97 1.1255
R3013 VSS.n138 VSS.n137 1.1255
R3014 VSS.n139 VSS.n138 1.1255
R3015 VSS.n139 VSS.n136 1.1255
R3016 VSS.n136 VSS.n135 1.1255
R3017 VSS.n135 VSS.n123 1.1255
R3018 VSS.n153 VSS.n123 1.1255
R3019 VSS.n154 VSS.n153 1.1255
R3020 VSS.n155 VSS.n154 1.1255
R3021 VSS.n728 VSS.n727 1.1255
R3022 VSS.n731 VSS.n728 1.1255
R3023 VSS.n732 VSS.n731 1.1255
R3024 VSS.n735 VSS.n732 1.1255
R3025 VSS.n736 VSS.n735 1.1255
R3026 VSS.n739 VSS.n736 1.1255
R3027 VSS.n740 VSS.n739 1.1255
R3028 VSS.n741 VSS.n740 1.1255
R3029 VSS.n741 VSS.n719 1.1255
R3030 VSS.n748 VSS.n747 1.1255
R3031 VSS.n749 VSS.n748 1.1255
R3032 VSS.n749 VSS.n102 1.1255
R3033 VSS.n755 VSS.n102 1.1255
R3034 VSS.n756 VSS.n755 1.1255
R3035 VSS.n757 VSS.n756 1.1255
R3036 VSS.n757 VSS.n92 1.1255
R3037 VSS.n766 VSS.n92 1.1255
R3038 VSS.n767 VSS.n766 1.1255
R3039 VSS.n768 VSS.n767 1.1255
R3040 VSS.n768 VSS.n91 1.1255
R3041 VSS.n141 VSS.n91 1.1255
R3042 VSS.n141 VSS.n129 1.1255
R3043 VSS.n147 VSS.n129 1.1255
R3044 VSS.n148 VSS.n147 1.1255
R3045 VSS.n149 VSS.n148 1.1255
R3046 VSS.n149 VSS.n128 1.1255
R3047 VSS.n128 VSS.n121 1.1255
R3048 VSS.n159 VSS.n158 1.1255
R3049 VSS.n162 VSS.n159 1.1255
R3050 VSS.n163 VSS.n162 1.1255
R3051 VSS.n166 VSS.n163 1.1255
R3052 VSS.n167 VSS.n166 1.1255
R3053 VSS.n170 VSS.n167 1.1255
R3054 VSS.n172 VSS.n170 1.1255
R3055 VSS.n173 VSS.n172 1.1255
R3056 VSS.n174 VSS.n173 1.1255
R3057 VSS.n459 VSS.n243 0.9905
R3058 VSS.n593 VSS.n516 0.9005
R3059 VSS.n563 VSS.n531 0.9005
R3060 VSS.n559 VSS.n553 0.9005
R3061 VSS.n553 VSS.n552 0.9005
R3062 VSS.n37 VSS.n36 0.9005
R3063 VSS.n38 VSS.n37 0.9005
R3064 VSS.n42 VSS.n41 0.9005
R3065 VSS.n83 VSS.n82 0.9005
R3066 VSS.n389 VSS.n388 0.9005
R3067 VSS.n388 VSS.n387 0.9005
R3068 VSS.n387 VSS.n386 0.9005
R3069 VSS.n386 VSS.n385 0.9005
R3070 VSS.n385 VSS.n384 0.9005
R3071 VSS.n444 VSS.n443 0.878
R3072 VSS.n297 VSS.n267 0.878
R3073 VSS.n727 VSS.n725 0.878
R3074 VSS.n598 VSS.n597 0.8405
R3075 VSS.n7 VSS.n1 0.8405
R3076 VSS.n331 VSS.t106 0.8195
R3077 VSS.n331 VSS.t107 0.8195
R3078 VSS.n332 VSS.t98 0.8195
R3079 VSS.n332 VSS.t104 0.8195
R3080 VSS.n566 VSS.n563 0.8105
R3081 VSS.n66 VSS.n42 0.8105
R3082 VSS.n539 VSS.n538 0.799908
R3083 VSS.n23 VSS.n22 0.799877
R3084 VSS.n579 VSS.n578 0.7805
R3085 VSS.n10 VSS.n8 0.7805
R3086 VSS.n468 VSS.n244 0.7655
R3087 VSS.n708 VSS.n188 0.7655
R3088 VSS.n344 VSS.n343 0.7655
R3089 VSS.n178 VSS.n177 0.73879
R3090 VSS.n314 VSS.n313 0.73879
R3091 VSS.n558 VSS.n531 0.6905
R3092 VSS.n41 VSS.n15 0.6905
R3093 VSS.n246 VSS.n244 0.6755
R3094 VSS.n399 VSS.n246 0.6755
R3095 VSS.n404 VSS.n399 0.6755
R3096 VSS.n405 VSS.n404 0.6755
R3097 VSS.n406 VSS.n405 0.6755
R3098 VSS.n406 VSS.n398 0.6755
R3099 VSS.n398 VSS.n397 0.6755
R3100 VSS.n397 VSS.n394 0.6755
R3101 VSS.n394 VSS.n393 0.6755
R3102 VSS.n469 VSS.n468 0.6755
R3103 VSS.n472 VSS.n469 0.6755
R3104 VSS.n473 VSS.n472 0.6755
R3105 VSS.n476 VSS.n473 0.6755
R3106 VSS.n477 VSS.n476 0.6755
R3107 VSS.n480 VSS.n477 0.6755
R3108 VSS.n481 VSS.n480 0.6755
R3109 VSS.n484 VSS.n481 0.6755
R3110 VSS.n485 VSS.n484 0.6755
R3111 VSS.n486 VSS.n485 0.6755
R3112 VSS.n486 VSS.n243 0.6755
R3113 VSS.n460 VSS.n459 0.6755
R3114 VSS.n460 VSS.n458 0.6755
R3115 VSS.n458 VSS.n457 0.6755
R3116 VSS.n457 VSS.n363 0.6755
R3117 VSS.n452 VSS.n363 0.6755
R3118 VSS.n452 VSS.n451 0.6755
R3119 VSS.n451 VSS.n450 0.6755
R3120 VSS.n450 VSS.n365 0.6755
R3121 VSS.n444 VSS.n365 0.6755
R3122 VSS.n415 VSS.n376 0.6755
R3123 VSS.n416 VSS.n415 0.6755
R3124 VSS.n417 VSS.n416 0.6755
R3125 VSS.n417 VSS.n372 0.6755
R3126 VSS.n428 VSS.n372 0.6755
R3127 VSS.n429 VSS.n428 0.6755
R3128 VSS.n430 VSS.n429 0.6755
R3129 VSS.n430 VSS.n371 0.6755
R3130 VSS.n371 VSS.n367 0.6755
R3131 VSS.n442 VSS.n367 0.6755
R3132 VSS.n443 VSS.n442 0.6755
R3133 VSS.n667 VSS.n202 0.6755
R3134 VSS.n202 VSS.n198 0.6755
R3135 VSS.n673 VSS.n198 0.6755
R3136 VSS.n674 VSS.n673 0.6755
R3137 VSS.n677 VSS.n674 0.6755
R3138 VSS.n678 VSS.n677 0.6755
R3139 VSS.n681 VSS.n678 0.6755
R3140 VSS.n682 VSS.n681 0.6755
R3141 VSS.n683 VSS.n682 0.6755
R3142 VSS.n683 VSS.n197 0.6755
R3143 VSS.n698 VSS.n695 0.6755
R3144 VSS.n700 VSS.n698 0.6755
R3145 VSS.n701 VSS.n700 0.6755
R3146 VSS.n703 VSS.n701 0.6755
R3147 VSS.n705 VSS.n703 0.6755
R3148 VSS.n706 VSS.n705 0.6755
R3149 VSS.n707 VSS.n706 0.6755
R3150 VSS.n708 VSS.n707 0.6755
R3151 VSS.n344 VSS.n326 0.6755
R3152 VSS.n326 VSS.n325 0.6755
R3153 VSS.n325 VSS.n254 0.6755
R3154 VSS.n291 VSS.n254 0.6755
R3155 VSS.n291 VSS.n290 0.6755
R3156 VSS.n290 VSS.n289 0.6755
R3157 VSS.n289 VSS.n269 0.6755
R3158 VSS.n279 VSS.n269 0.6755
R3159 VSS.n279 VSS.n278 0.6755
R3160 VSS.n278 VSS.n277 0.6755
R3161 VSS.n659 VSS.n204 0.6755
R3162 VSS.n327 VSS.n204 0.6755
R3163 VSS.n330 VSS.n327 0.6755
R3164 VSS.n338 VSS.n335 0.6755
R3165 VSS.n339 VSS.n338 0.6755
R3166 VSS.n342 VSS.n339 0.6755
R3167 VSS.n343 VSS.n342 0.6755
R3168 VSS.n689 VSS.n189 0.653
R3169 VSS.n317 VSS.n316 0.653
R3170 VSS.n623 VSS.n496 0.653
R3171 VSS.n747 VSS.n110 0.653
R3172 VSS.n175 VSS.n121 0.653
R3173 VSS.n549 VSS.n534 0.5855
R3174 VSS.n33 VSS.n18 0.5855
R3175 VSS.n601 VSS.n511 0.518
R3176 VSS.n155 VSS.n2 0.518
R3177 VSS.n589 VSS.n588 0.5105
R3178 VSS.n73 VSS.n72 0.5105
R3179 VSS.n393 VSS.n391 0.47417
R3180 VSS.n197 VSS.n189 0.4505
R3181 VSS.n695 VSS.n694 0.4505
R3182 VSS.n277 VSS.n188 0.4505
R3183 VSS.n664 VSS.n659 0.4505
R3184 VSS.n409 VSS.n379 0.430889
R3185 VSS.n409 VSS.n380 0.430889
R3186 VSS.n488 VSS.n240 0.430889
R3187 VSS.n488 VSS.n239 0.430889
R3188 VSS.n488 VSS.n238 0.430889
R3189 VSS.n488 VSS.n237 0.430889
R3190 VSS.n488 VSS.n236 0.430889
R3191 VSS.n446 VSS.n192 0.430889
R3192 VSS.n448 VSS.n192 0.430889
R3193 VSS.n454 VSS.n200 0.430889
R3194 VSS.n686 VSS.n685 0.430889
R3195 VSS.n686 VSS.n195 0.430889
R3196 VSS.n686 VSS.n194 0.430889
R3197 VSS.n686 VSS.n193 0.430889
R3198 VSS.n711 VSS.n183 0.430889
R3199 VSS.n711 VSS.n182 0.430889
R3200 VSS.n711 VSS.n180 0.430889
R3201 VSS.n711 VSS.n710 0.430889
R3202 VSS.n656 VSS.n207 0.430889
R3203 VSS.n656 VSS.n208 0.430889
R3204 VSS.n656 VSS.n209 0.430889
R3205 VSS.n656 VSS.n210 0.430889
R3206 VSS.n657 VSS.n656 0.430889
R3207 VSS.n670 VSS.n669 0.430889
R3208 VSS.n599 VSS.n598 0.409133
R3209 VSS.n773 VSS.n1 0.409133
R3210 VSS.n592 VSS.n515 0.4005
R3211 VSS.n592 VSS.n591 0.4005
R3212 VSS.n591 VSS.n590 0.4005
R3213 VSS.n590 VSS.n517 0.4005
R3214 VSS.n562 VSS.n517 0.4005
R3215 VSS.n562 VSS.n561 0.4005
R3216 VSS.n561 VSS.n560 0.4005
R3217 VSS.n560 VSS.n532 0.4005
R3218 VSS.n551 VSS.n532 0.4005
R3219 VSS.n551 VSS.n550 0.4005
R3220 VSS.n35 VSS.n34 0.4005
R3221 VSS.n35 VSS.n16 0.4005
R3222 VSS.n39 VSS.n16 0.4005
R3223 VSS.n40 VSS.n39 0.4005
R3224 VSS.n40 VSS.n9 0.4005
R3225 VSS.n70 VSS.n9 0.4005
R3226 VSS.n71 VSS.n70 0.4005
R3227 VSS.n71 VSS.n3 0.4005
R3228 VSS.n84 VSS.n3 0.4005
R3229 VSS.n85 VSS.n84 0.4005
R3230 VSS.n667 VSS.n666 0.37175
R3231 VSS.n334 VSS.n330 0.3605
R3232 VSS.n603 VSS.n601 0.3605
R3233 VSS.n158 VSS.n2 0.3605
R3234 VSS.n316 VSS.n258 0.338
R3235 VSS.n505 VSS.n496 0.338
R3236 VSS.n719 VSS.n110 0.338
R3237 VSS.n175 VSS.n174 0.338
R3238 VSS.n548 VSS.n547 0.3305
R3239 VSS.n32 VSS.n31 0.3305
R3240 VSS.n335 VSS.n334 0.3155
R3241 VSS.n552 VSS.n534 0.3155
R3242 VSS.n36 VSS.n18 0.3155
R3243 VSS.n666 VSS.n665 0.28175
R3244 VSS.n744 VSS.n743 0.2772
R3245 VSS.n744 VSS.n716 0.2772
R3246 VSS.n744 VSS.n715 0.2772
R3247 VSS.n744 VSS.n714 0.2772
R3248 VSS.n744 VSS.n713 0.2772
R3249 VSS.n178 VSS.n114 0.2772
R3250 VSS.n178 VSS.n116 0.2772
R3251 VSS.n178 VSS.n113 0.2772
R3252 VSS.n178 VSS.n117 0.2772
R3253 VSS.n313 VSS.n263 0.2772
R3254 VSS.n313 VSS.n264 0.2772
R3255 VSS.n313 VSS.n261 0.2772
R3256 VSS.n313 VSS.n265 0.2772
R3257 VSS.n620 VSS.n619 0.2772
R3258 VSS.n620 VSS.n502 0.2772
R3259 VSS.n620 VSS.n501 0.2772
R3260 VSS.n620 VSS.n500 0.2772
R3261 VSS.n620 VSS.n499 0.2772
R3262 VSS.n774 VSS.n0 0.2255
R3263 VSS.n694 VSS.n689 0.2255
R3264 VSS.n665 VSS.n664 0.2255
R3265 VSS.n559 VSS.n558 0.2105
R3266 VSS.n38 VSS.n15 0.2105
R3267 VSS.n535 VSS.t372 0.20525
R3268 VSS.n535 VSS.t370 0.20525
R3269 VSS.n536 VSS.t33 0.20525
R3270 VSS.n536 VSS.t31 0.20525
R3271 VSS.n540 VSS.t41 0.20525
R3272 VSS.n540 VSS.t120 0.20525
R3273 VSS.n541 VSS.t14 0.20525
R3274 VSS.n541 VSS.t174 0.20525
R3275 VSS.n543 VSS.t365 0.20525
R3276 VSS.n543 VSS.t43 0.20525
R3277 VSS.n545 VSS.t176 0.20525
R3278 VSS.n545 VSS.t116 0.20525
R3279 VSS.n533 VSS.t12 0.20525
R3280 VSS.n533 VSS.t204 0.20525
R3281 VSS.n564 VSS.t37 0.20525
R3282 VSS.n564 VSS.t10 0.20525
R3283 VSS.n581 VSS.t261 0.20525
R3284 VSS.n581 VSS.t118 0.20525
R3285 VSS.n582 VSS.t288 0.20525
R3286 VSS.n582 VSS.t357 0.20525
R3287 VSS.n584 VSS.t300 0.20525
R3288 VSS.n584 VSS.t259 0.20525
R3289 VSS.n585 VSS.t234 0.20525
R3290 VSS.n585 VSS.t290 0.20525
R3291 VSS.n594 VSS.t18 0.20525
R3292 VSS.n594 VSS.t285 0.20525
R3293 VSS.n595 VSS.t124 0.20525
R3294 VSS.n595 VSS.t56 0.20525
R3295 VSS.n4 VSS.t265 0.20525
R3296 VSS.n4 VSS.t263 0.20525
R3297 VSS.n5 VSS.t294 0.20525
R3298 VSS.n5 VSS.t292 0.20525
R3299 VSS.n79 VSS.t272 0.20525
R3300 VSS.n79 VSS.t361 0.20525
R3301 VSS.n77 VSS.t76 0.20525
R3302 VSS.n77 VSS.t206 0.20525
R3303 VSS.n75 VSS.t208 0.20525
R3304 VSS.n75 VSS.t359 0.20525
R3305 VSS.n74 VSS.t367 0.20525
R3306 VSS.n74 VSS.t270 0.20525
R3307 VSS.n67 VSS.t6 0.20525
R3308 VSS.n67 VSS.t59 0.20525
R3309 VSS.n17 VSS.t304 0.20525
R3310 VSS.n17 VSS.t302 0.20525
R3311 VSS.n29 VSS.t355 0.20525
R3312 VSS.n29 VSS.t198 0.20525
R3313 VSS.n27 VSS.t210 0.20525
R3314 VSS.n27 VSS.t200 0.20525
R3315 VSS.n25 VSS.t230 0.20525
R3316 VSS.n25 VSS.t232 0.20525
R3317 VSS.n24 VSS.t185 0.20525
R3318 VSS.n24 VSS.t363 0.20525
R3319 VSS.n19 VSS.t25 0.20525
R3320 VSS.n19 VSS.t23 0.20525
R3321 VSS.n20 VSS.t73 0.20525
R3322 VSS.n20 VSS.t71 0.20525
R3323 VSS.n580 VSS.n516 0.1955
R3324 VSS.n588 VSS.n580 0.1955
R3325 VSS.n547 VSS.n539 0.1955
R3326 VSS.n31 VSS.n23 0.1955
R3327 VSS.n81 VSS.n73 0.1955
R3328 VSS.n82 VSS.n81 0.1955
R3329 VSS.n546 VSS.n544 0.189974
R3330 VSS.n544 VSS.n542 0.189974
R3331 VSS.n574 VSS.n572 0.189974
R3332 VSS.n576 VSS.n574 0.189974
R3333 VSS.n569 VSS.n567 0.189974
R3334 VSS.n567 VSS.n529 0.189974
R3335 VSS.n529 VSS.n527 0.189974
R3336 VSS.n527 VSS.n525 0.189974
R3337 VSS.n525 VSS.n523 0.189974
R3338 VSS.n523 VSS.n521 0.189974
R3339 VSS.n587 VSS.n586 0.189974
R3340 VSS.n587 VSS.n583 0.189974
R3341 VSS.n78 VSS.n76 0.189974
R3342 VSS.n80 VSS.n78 0.189974
R3343 VSS.n57 VSS.n55 0.189974
R3344 VSS.n59 VSS.n57 0.189974
R3345 VSS.n61 VSS.n59 0.189974
R3346 VSS.n63 VSS.n61 0.189974
R3347 VSS.n65 VSS.n63 0.189974
R3348 VSS.n65 VSS.n52 0.189974
R3349 VSS.n49 VSS.n47 0.189974
R3350 VSS.n47 VSS.n45 0.189974
R3351 VSS.n28 VSS.n26 0.189974
R3352 VSS.n30 VSS.n28 0.189974
R3353 VSS.n391 VSS.n376 0.178383
R3354 VSS.n600 VSS.n515 0.167167
R3355 VSS.n772 VSS.n85 0.167167
R3356 VSS.n549 VSS.n548 0.1655
R3357 VSS.n33 VSS.n32 0.1655
R3358 VSS.n554 VSS.t280 0.1643
R3359 VSS.n554 VSS.t282 0.1643
R3360 VSS.n555 VSS.t278 0.1643
R3361 VSS.n555 VSS.t274 0.1643
R3362 VSS.n519 VSS.t168 0.1643
R3363 VSS.n519 VSS.t170 0.1643
R3364 VSS.n520 VSS.t164 0.1643
R3365 VSS.n520 VSS.t166 0.1643
R3366 VSS.n522 VSS.t160 0.1643
R3367 VSS.n522 VSS.t162 0.1643
R3368 VSS.n524 VSS.t156 0.1643
R3369 VSS.n524 VSS.t158 0.1643
R3370 VSS.n526 VSS.t152 0.1643
R3371 VSS.n526 VSS.t154 0.1643
R3372 VSS.n528 VSS.t148 0.1643
R3373 VSS.n528 VSS.t150 0.1643
R3374 VSS.n530 VSS.t144 0.1643
R3375 VSS.n530 VSS.t146 0.1643
R3376 VSS.n568 VSS.t140 0.1643
R3377 VSS.n568 VSS.t142 0.1643
R3378 VSS.n575 VSS.t137 0.1643
R3379 VSS.n575 VSS.t138 0.1643
R3380 VSS.n573 VSS.t134 0.1643
R3381 VSS.n573 VSS.t136 0.1643
R3382 VSS.n571 VSS.t130 0.1643
R3383 VSS.n571 VSS.t132 0.1643
R3384 VSS.n570 VSS.t126 0.1643
R3385 VSS.n570 VSS.t128 0.1643
R3386 VSS.n660 VSS.t108 0.1643
R3387 VSS.n660 VSS.t110 0.1643
R3388 VSS.n662 VSS.t103 0.1643
R3389 VSS.n662 VSS.t102 0.1643
R3390 VSS.n690 VSS.t113 0.1643
R3391 VSS.n690 VSS.t114 0.1643
R3392 VSS.n691 VSS.t111 0.1643
R3393 VSS.n691 VSS.t100 0.1643
R3394 VSS.n43 VSS.t350 0.1643
R3395 VSS.n43 VSS.t352 0.1643
R3396 VSS.n44 VSS.t346 0.1643
R3397 VSS.n44 VSS.t348 0.1643
R3398 VSS.n46 VSS.t342 0.1643
R3399 VSS.n46 VSS.t344 0.1643
R3400 VSS.n48 VSS.t339 0.1643
R3401 VSS.n48 VSS.t340 0.1643
R3402 VSS.n51 VSS.t336 0.1643
R3403 VSS.n51 VSS.t338 0.1643
R3404 VSS.n64 VSS.t324 0.1643
R3405 VSS.n64 VSS.t334 0.1643
R3406 VSS.n62 VSS.t330 0.1643
R3407 VSS.n62 VSS.t332 0.1643
R3408 VSS.n60 VSS.t326 0.1643
R3409 VSS.n60 VSS.t328 0.1643
R3410 VSS.n58 VSS.t320 0.1643
R3411 VSS.n58 VSS.t322 0.1643
R3412 VSS.n56 VSS.t316 0.1643
R3413 VSS.n56 VSS.t318 0.1643
R3414 VSS.n54 VSS.t312 0.1643
R3415 VSS.n54 VSS.t314 0.1643
R3416 VSS.n53 VSS.t308 0.1643
R3417 VSS.n53 VSS.t310 0.1643
R3418 VSS.n12 VSS.t223 0.1643
R3419 VSS.n12 VSS.t225 0.1643
R3420 VSS.n11 VSS.t219 0.1643
R3421 VSS.n11 VSS.t221 0.1643
R3422 VSS.n693 VSS.n692 0.118945
R3423 VSS.n577 VSS.n569 0.118921
R3424 VSS.n52 VSS.n50 0.118921
R3425 VSS.n663 VSS.n661 0.117954
R3426 VSS.n578 VSS.n518 0.1055
R3427 VSS.n69 VSS.n10 0.1055
R3428 VSS.n566 VSS.n565 0.0755
R3429 VSS.n68 VSS.n66 0.0755
R3430 VSS.n577 VSS.n576 0.0715526
R3431 VSS.n50 VSS.n49 0.0715526
R3432 VSS.n597 VSS.n593 0.0605
R3433 VSS.n83 VSS.n7 0.0605
R3434 VSS.n557 VSS.n556 0.0478684
R3435 VSS.n14 VSS.n13 0.0478684
R3436 VSS VSS.n774 0.0455
R3437 VSS.n589 VSS.n579 0.0155
R3438 VSS.n565 VSS.n518 0.0155
R3439 VSS.n69 VSS.n68 0.0155
R3440 VSS.n72 VSS.n8 0.0155
R3441 a_n6400_n23452.n1 a_n6400_n23452.t1 16.0839
R3442 a_n6400_n23452.n1 a_n6400_n23452.n0 12.3065
R3443 a_n6400_n23452.n2 a_n6400_n23452.n1 10.9378
R3444 a_n6400_n23452.n0 a_n6400_n23452.t3 0.1825
R3445 a_n6400_n23452.n0 a_n6400_n23452.t4 0.1825
R3446 a_n6400_n23452.t0 a_n6400_n23452.n2 0.1643
R3447 a_n6400_n23452.n2 a_n6400_n23452.t2 0.1643
R3448 a_n7157_n23500.n1 a_n7157_n23500.t1 16.0839
R3449 a_n7157_n23500.n0 a_n7157_n23500.t0 6.66284
R3450 a_n7157_n23500.t3 a_n7157_n23500.n2 6.62866
R3451 a_n7157_n23500.n0 a_n7157_n23500.t2 6.45713
R3452 a_n7157_n23500.n2 a_n7157_n23500.t4 6.42295
R3453 a_n7157_n23500.n1 a_n7157_n23500.n0 5.97129
R3454 a_n7157_n23500.n2 a_n7157_n23500.n1 4.55024
R3455 a_n10800_n23372.n0 a_n10800_n23372.t3 139.69
R3456 a_n10800_n23372.n0 a_n10800_n23372.t2 139.69
R3457 a_n10800_n23372.n1 a_n10800_n23372.n0 36.7175
R3458 a_n10800_n23372.n1 a_n10800_n23372.t0 14.2148
R3459 a_n10800_n23372.t1 a_n10800_n23372.n1 11.6368
R3460 a_n6400_n21652.n1 a_n6400_n21652.t2 16.0839
R3461 a_n6400_n21652.n2 a_n6400_n21652.n1 12.3065
R3462 a_n6400_n21652.n1 a_n6400_n21652.n0 10.9378
R3463 a_n6400_n21652.t0 a_n6400_n21652.n2 0.1825
R3464 a_n6400_n21652.n2 a_n6400_n21652.t1 0.1825
R3465 a_n6400_n21652.n0 a_n6400_n21652.t3 0.1643
R3466 a_n6400_n21652.n0 a_n6400_n21652.t4 0.1643
R3467 a_n7157_n21700.n1 a_n7157_n21700.t3 16.0839
R3468 a_n7157_n21700.n0 a_n7157_n21700.t2 6.66284
R3469 a_n7157_n21700.n2 a_n7157_n21700.t0 6.62866
R3470 a_n7157_n21700.n0 a_n7157_n21700.t4 6.45713
R3471 a_n7157_n21700.t1 a_n7157_n21700.n2 6.42295
R3472 a_n7157_n21700.n1 a_n7157_n21700.n0 5.97129
R3473 a_n7157_n21700.n2 a_n7157_n21700.n1 4.55024
R3474 a_n10800_n21572.n0 a_n10800_n21572.t3 139.69
R3475 a_n10800_n21572.n0 a_n10800_n21572.t2 139.69
R3476 a_n10800_n21572.n1 a_n10800_n21572.n0 36.7175
R3477 a_n10800_n21572.n1 a_n10800_n21572.t0 14.2148
R3478 a_n10800_n21572.t1 a_n10800_n21572.n1 11.6368
R3479 a_n6400_n19852.n1 a_n6400_n19852.t0 16.1006
R3480 a_n6400_n19852.n1 a_n6400_n19852.n0 12.3065
R3481 a_n6400_n19852.n2 a_n6400_n19852.n1 10.9378
R3482 a_n6400_n19852.n0 a_n6400_n19852.t3 0.1825
R3483 a_n6400_n19852.n0 a_n6400_n19852.t2 0.1825
R3484 a_n6400_n19852.n2 a_n6400_n19852.t4 0.1643
R3485 a_n6400_n19852.t1 a_n6400_n19852.n2 0.1643
R3486 a_n7300_n19900.n1 a_n7300_n19900.t1 16.1006
R3487 a_n7300_n19900.n0 a_n7300_n19900.t4 6.66284
R3488 a_n7300_n19900.n2 a_n7300_n19900.t2 6.62866
R3489 a_n7300_n19900.n0 a_n7300_n19900.t0 6.45713
R3490 a_n7300_n19900.t3 a_n7300_n19900.n2 6.42295
R3491 a_n7300_n19900.n1 a_n7300_n19900.n0 5.97129
R3492 a_n7300_n19900.n2 a_n7300_n19900.n1 4.55024
R3493 a_n10800_n19772.n0 a_n10800_n19772.t3 139.69
R3494 a_n10800_n19772.n0 a_n10800_n19772.t2 139.69
R3495 a_n10800_n19772.n1 a_n10800_n19772.n0 36.7175
R3496 a_n10800_n19772.n1 a_n10800_n19772.t0 14.2148
R3497 a_n10800_n19772.t1 a_n10800_n19772.n1 11.6368
R3498 a_n6400_n18052.n1 a_n6400_n18052.t2 16.1006
R3499 a_n6400_n18052.n1 a_n6400_n18052.n0 12.3065
R3500 a_n6400_n18052.n2 a_n6400_n18052.n1 10.9378
R3501 a_n6400_n18052.n0 a_n6400_n18052.t4 0.1825
R3502 a_n6400_n18052.n0 a_n6400_n18052.t3 0.1825
R3503 a_n6400_n18052.t0 a_n6400_n18052.n2 0.1643
R3504 a_n6400_n18052.n2 a_n6400_n18052.t1 0.1643
R3505 a_n7300_n18100.n1 a_n7300_n18100.t0 16.1006
R3506 a_n7300_n18100.n0 a_n7300_n18100.t1 6.66284
R3507 a_n7300_n18100.t3 a_n7300_n18100.n2 6.62866
R3508 a_n7300_n18100.n0 a_n7300_n18100.t2 6.45713
R3509 a_n7300_n18100.n2 a_n7300_n18100.t4 6.42295
R3510 a_n7300_n18100.n1 a_n7300_n18100.n0 5.97129
R3511 a_n7300_n18100.n2 a_n7300_n18100.n1 4.55024
R3512 a_n10800_n17972.n0 a_n10800_n17972.t3 139.69
R3513 a_n10800_n17972.n0 a_n10800_n17972.t2 139.69
R3514 a_n10800_n17972.n1 a_n10800_n17972.n0 36.7175
R3515 a_n10800_n17972.n1 a_n10800_n17972.t0 14.2148
R3516 a_n10800_n17972.t1 a_n10800_n17972.n1 11.6368
R3517 a_n6400_n16252.n1 a_n6400_n16252.t0 16.1006
R3518 a_n6400_n16252.n1 a_n6400_n16252.n0 12.3065
R3519 a_n6400_n16252.n2 a_n6400_n16252.n1 10.9378
R3520 a_n6400_n16252.n0 a_n6400_n16252.t3 0.1825
R3521 a_n6400_n16252.n0 a_n6400_n16252.t2 0.1825
R3522 a_n6400_n16252.n2 a_n6400_n16252.t4 0.1643
R3523 a_n6400_n16252.t1 a_n6400_n16252.n2 0.1643
R3524 a_n7300_n16300.n1 a_n7300_n16300.t0 16.1006
R3525 a_n7300_n16300.n0 a_n7300_n16300.t4 6.66284
R3526 a_n7300_n16300.n2 a_n7300_n16300.t2 6.62866
R3527 a_n7300_n16300.n0 a_n7300_n16300.t1 6.45713
R3528 a_n7300_n16300.t3 a_n7300_n16300.n2 6.42295
R3529 a_n7300_n16300.n1 a_n7300_n16300.n0 5.97129
R3530 a_n7300_n16300.n2 a_n7300_n16300.n1 4.55024
R3531 a_n10800_n16172.n0 a_n10800_n16172.t3 139.69
R3532 a_n10800_n16172.n0 a_n10800_n16172.t2 139.69
R3533 a_n10800_n16172.n1 a_n10800_n16172.n0 36.7175
R3534 a_n10800_n16172.n1 a_n10800_n16172.t0 14.2148
R3535 a_n10800_n16172.t1 a_n10800_n16172.n1 11.6368
R3536 a_n6400_n14452.n1 a_n6400_n14452.t1 16.1006
R3537 a_n6400_n14452.n1 a_n6400_n14452.n0 12.3065
R3538 a_n6400_n14452.n2 a_n6400_n14452.n1 10.9378
R3539 a_n6400_n14452.n0 a_n6400_n14452.t3 0.1825
R3540 a_n6400_n14452.n0 a_n6400_n14452.t4 0.1825
R3541 a_n6400_n14452.t0 a_n6400_n14452.n2 0.1643
R3542 a_n6400_n14452.n2 a_n6400_n14452.t2 0.1643
R3543 a_n7300_n14500.n1 a_n7300_n14500.t4 16.1006
R3544 a_n7300_n14500.n0 a_n7300_n14500.t0 6.66284
R3545 a_n7300_n14500.n2 a_n7300_n14500.t2 6.62866
R3546 a_n7300_n14500.n0 a_n7300_n14500.t1 6.45713
R3547 a_n7300_n14500.t3 a_n7300_n14500.n2 6.42295
R3548 a_n7300_n14500.n1 a_n7300_n14500.n0 5.97129
R3549 a_n7300_n14500.n2 a_n7300_n14500.n1 4.55024
R3550 a_n10800_n14372.n0 a_n10800_n14372.t3 139.69
R3551 a_n10800_n14372.n0 a_n10800_n14372.t2 139.69
R3552 a_n10800_n14372.n1 a_n10800_n14372.n0 36.7175
R3553 a_n10800_n14372.n1 a_n10800_n14372.t0 14.2148
R3554 a_n10800_n14372.t1 a_n10800_n14372.n1 11.6368
R3555 a_n6400_n12652.n1 a_n6400_n12652.t4 16.1006
R3556 a_n6400_n12652.n2 a_n6400_n12652.n1 12.3065
R3557 a_n6400_n12652.n1 a_n6400_n12652.n0 10.9378
R3558 a_n6400_n12652.t0 a_n6400_n12652.n2 0.1825
R3559 a_n6400_n12652.n2 a_n6400_n12652.t1 0.1825
R3560 a_n6400_n12652.n0 a_n6400_n12652.t2 0.1643
R3561 a_n6400_n12652.n0 a_n6400_n12652.t3 0.1643
R3562 a_n7300_n12700.n1 a_n7300_n12700.t2 16.1006
R3563 a_n7300_n12700.n0 a_n7300_n12700.t3 6.66284
R3564 a_n7300_n12700.n2 a_n7300_n12700.t0 6.62866
R3565 a_n7300_n12700.n0 a_n7300_n12700.t4 6.45713
R3566 a_n7300_n12700.t1 a_n7300_n12700.n2 6.42295
R3567 a_n7300_n12700.n1 a_n7300_n12700.n0 5.97129
R3568 a_n7300_n12700.n2 a_n7300_n12700.n1 4.55024
R3569 a_n10800_n12572.n0 a_n10800_n12572.t3 139.69
R3570 a_n10800_n12572.n0 a_n10800_n12572.t2 139.69
R3571 a_n10800_n12572.n1 a_n10800_n12572.n0 36.7175
R3572 a_n10800_n12572.n1 a_n10800_n12572.t0 14.2148
R3573 a_n10800_n12572.t1 a_n10800_n12572.n1 11.6368
R3574 a_2148_n500.n5 a_2148_n500.n3 10.5451
R3575 a_2148_n500.n5 a_2148_n500.n4 10.5451
R3576 a_2148_n500.n2 a_2148_n500.t1 6.45713
R3577 a_2148_n500.n8 a_2148_n500.n7 6.38754
R3578 a_2148_n500.n1 a_2148_n500.n0 6.29333
R3579 a_2148_n500.n6 a_2148_n500.n2 4.68405
R3580 a_2148_n500.n7 a_2148_n500.n6 2.22659
R3581 a_2148_n500.n6 a_2148_n500.n5 0.8055
R3582 a_2148_n500.n3 a_2148_n500.t8 0.3281
R3583 a_2148_n500.n3 a_2148_n500.t0 0.3281
R3584 a_2148_n500.n4 a_2148_n500.t6 0.3281
R3585 a_2148_n500.n4 a_2148_n500.t7 0.3281
R3586 a_2148_n500.n2 a_2148_n500.n1 0.189974
R3587 a_2148_n500.n8 a_2148_n500.t4 0.1643
R3588 a_2148_n500.t5 a_2148_n500.n8 0.1643
R3589 a_2148_n500.n0 a_2148_n500.t2 0.1643
R3590 a_2148_n500.n0 a_2148_n500.t3 0.1643
R3591 a_2148_n500.n7 a_2148_n500.n1 0.0928953
R3592 a_n5052_n1000.n5 a_n5052_n1000.n3 11.1933
R3593 a_n5052_n1000.n5 a_n5052_n1000.n4 11.1933
R3594 a_n5052_n1000.n2 a_n5052_n1000.t2 6.45713
R3595 a_n5052_n1000.n8 a_n5052_n1000.n7 6.38754
R3596 a_n5052_n1000.n1 a_n5052_n1000.n0 6.29333
R3597 a_n5052_n1000.n6 a_n5052_n1000.n2 4.68405
R3598 a_n5052_n1000.n7 a_n5052_n1000.n6 2.22659
R3599 a_n5052_n1000.n6 a_n5052_n1000.n5 0.5555
R3600 a_n5052_n1000.n2 a_n5052_n1000.n1 0.189974
R3601 a_n5052_n1000.n8 a_n5052_n1000.t5 0.1643
R3602 a_n5052_n1000.t6 a_n5052_n1000.n8 0.1643
R3603 a_n5052_n1000.n0 a_n5052_n1000.t3 0.1643
R3604 a_n5052_n1000.n0 a_n5052_n1000.t4 0.1643
R3605 a_n5052_n1000.n3 a_n5052_n1000.t0 0.1643
R3606 a_n5052_n1000.n3 a_n5052_n1000.t1 0.1643
R3607 a_n5052_n1000.n4 a_n5052_n1000.t7 0.1643
R3608 a_n5052_n1000.n4 a_n5052_n1000.t8 0.1643
R3609 a_n5052_n1000.n7 a_n5052_n1000.n1 0.0928953
R3610 a_n5052_2600.t3 a_n5052_2600.n4 7.27134
R3611 a_n5052_2600.n4 a_n5052_2600.t0 7.27134
R3612 a_n5052_2600.n2 a_n5052_2600.n0 6.71615
R3613 a_n5052_2600.n2 a_n5052_2600.n1 6.71615
R3614 a_n5052_2600.n4 a_n5052_2600.n3 6.31615
R3615 a_n5052_2600.n0 a_n5052_2600.t7 0.8195
R3616 a_n5052_2600.n0 a_n5052_2600.t6 0.8195
R3617 a_n5052_2600.n1 a_n5052_2600.t5 0.8195
R3618 a_n5052_2600.n1 a_n5052_2600.t4 0.8195
R3619 a_n5052_2600.n3 a_n5052_2600.t1 0.8195
R3620 a_n5052_2600.n3 a_n5052_2600.t2 0.8195
R3621 a_n5052_2600.n4 a_n5052_2600.n2 0.3955
R3622 a_5300_5958.t0 a_5300_5958.t1 26.7478
R3623 a_484_3500.t0 a_484_3500.t1 26.7478
R3624 a_n1900_5958.t0 a_n1900_5958.t1 26.7478
R3625 a_n3600_5641.n3 a_n3600_5641.t6 74.5091
R3626 a_n3600_5641.n3 a_n3600_5641.t7 74.5091
R3627 a_n3600_5641.n4 a_n3600_5641.n3 37.8057
R3628 a_n3600_5641.n1 a_n3600_5641.t5 13.0154
R3629 a_n3600_5641.n1 a_n3600_5641.t2 10.6142
R3630 a_n3600_5641.n0 a_n3600_5641.t3 7.23009
R3631 a_n3600_5641.n0 a_n3600_5641.t4 7.22685
R3632 a_n3600_5641.n5 a_n3600_5641.t0 6.55206
R3633 a_n3600_5641.t1 a_n3600_5641.n5 6.54882
R3634 a_n3600_5641.n5 a_n3600_5641.n4 2.75982
R3635 a_n3600_5641.n2 a_n3600_5641.n0 2.26891
R3636 a_n3600_5641.n2 a_n3600_5641.n1 0.425955
R3637 a_n3600_5641.n4 a_n3600_5641.n2 0.393227
R3638 a_n6572_3500.n3 a_n6572_3500.t6 74.5091
R3639 a_n6572_3500.n3 a_n6572_3500.t7 74.5091
R3640 a_n6572_3500.n4 a_n6572_3500.n3 37.5518
R3641 a_n6572_3500.n1 a_n6572_3500.t0 13.0154
R3642 a_n6572_3500.n1 a_n6572_3500.t1 10.6142
R3643 a_n6572_3500.n0 a_n6572_3500.t5 7.23009
R3644 a_n6572_3500.n0 a_n6572_3500.t4 7.22685
R3645 a_n6572_3500.t3 a_n6572_3500.n5 6.55206
R3646 a_n6572_3500.n5 a_n6572_3500.t2 6.54882
R3647 a_n6572_3500.n5 a_n6572_3500.n4 2.59618
R3648 a_n6572_3500.n2 a_n6572_3500.n0 2.26891
R3649 a_n6572_3500.n4 a_n6572_3500.n2 0.556864
R3650 a_n6572_3500.n2 a_n6572_3500.n1 0.425955
R3651 a_n6716_3500.t0 a_n6716_3500.t1 26.7478
R3652 XFE_O.NTAIL.n29 XFE_O.NTAIL.n22 13.0309
R3653 XFE_O.NTAIL.n29 XFE_O.NTAIL.n28 11.5048
R3654 XFE_O.NTAIL.n41 XFE_O.NTAIL.n40 11.5048
R3655 XFE_O.NTAIL.n34 XFE_O.NTAIL.n33 9.03963
R3656 XFE_O.NTAIL.n1 XFE_O.NTAIL.t44 5.82877
R3657 XFE_O.NTAIL.n13 XFE_O.NTAIL.t21 5.82877
R3658 XFE_O.NTAIL.n33 XFE_O.NTAIL.t8 5.78141
R3659 XFE_O.NTAIL.n32 XFE_O.NTAIL.n30 5.66497
R3660 XFE_O.NTAIL.n28 XFE_O.NTAIL.n23 5.57485
R3661 XFE_O.NTAIL.n27 XFE_O.NTAIL.n25 5.57485
R3662 XFE_O.NTAIL.n40 XFE_O.NTAIL.n35 5.57485
R3663 XFE_O.NTAIL.n39 XFE_O.NTAIL.n37 5.57485
R3664 XFE_O.NTAIL.n1 XFE_O.NTAIL.n0 5.4755
R3665 XFE_O.NTAIL.n32 XFE_O.NTAIL.n31 5.4755
R3666 XFE_O.NTAIL.n3 XFE_O.NTAIL.n2 5.4755
R3667 XFE_O.NTAIL.n5 XFE_O.NTAIL.n4 5.4755
R3668 XFE_O.NTAIL.n7 XFE_O.NTAIL.n6 5.4755
R3669 XFE_O.NTAIL.n9 XFE_O.NTAIL.n8 5.4755
R3670 XFE_O.NTAIL.n11 XFE_O.NTAIL.n10 5.4755
R3671 XFE_O.NTAIL.n21 XFE_O.NTAIL.n20 5.4755
R3672 XFE_O.NTAIL.n19 XFE_O.NTAIL.n18 5.4755
R3673 XFE_O.NTAIL.n17 XFE_O.NTAIL.n16 5.4755
R3674 XFE_O.NTAIL.n15 XFE_O.NTAIL.n14 5.4755
R3675 XFE_O.NTAIL.n13 XFE_O.NTAIL.n12 5.4755
R3676 XFE_O.NTAIL.n28 XFE_O.NTAIL.n24 5.38537
R3677 XFE_O.NTAIL.n27 XFE_O.NTAIL.n26 5.38537
R3678 XFE_O.NTAIL.n40 XFE_O.NTAIL.n36 5.38537
R3679 XFE_O.NTAIL.n39 XFE_O.NTAIL.n38 5.38537
R3680 XFE_O.NTAIL.n34 XFE_O.NTAIL.n29 2.27007
R3681 XFE_O.NTAIL.n41 XFE_O.NTAIL.n34 0.86137
R3682 XFE_O.NTAIL.n23 XFE_O.NTAIL.t6 0.20525
R3683 XFE_O.NTAIL.n23 XFE_O.NTAIL.t7 0.20525
R3684 XFE_O.NTAIL.n24 XFE_O.NTAIL.t4 0.20525
R3685 XFE_O.NTAIL.n24 XFE_O.NTAIL.t5 0.20525
R3686 XFE_O.NTAIL.n26 XFE_O.NTAIL.t2 0.20525
R3687 XFE_O.NTAIL.n26 XFE_O.NTAIL.t3 0.20525
R3688 XFE_O.NTAIL.n25 XFE_O.NTAIL.t0 0.20525
R3689 XFE_O.NTAIL.n25 XFE_O.NTAIL.t1 0.20525
R3690 XFE_O.NTAIL.n35 XFE_O.NTAIL.t19 0.20525
R3691 XFE_O.NTAIL.n35 XFE_O.NTAIL.t20 0.20525
R3692 XFE_O.NTAIL.n36 XFE_O.NTAIL.t17 0.20525
R3693 XFE_O.NTAIL.n36 XFE_O.NTAIL.t18 0.20525
R3694 XFE_O.NTAIL.n38 XFE_O.NTAIL.t15 0.20525
R3695 XFE_O.NTAIL.n38 XFE_O.NTAIL.t16 0.20525
R3696 XFE_O.NTAIL.n37 XFE_O.NTAIL.t13 0.20525
R3697 XFE_O.NTAIL.n37 XFE_O.NTAIL.t14 0.20525
R3698 XFE_O.NTAIL.n15 XFE_O.NTAIL.n13 0.189974
R3699 XFE_O.NTAIL.n17 XFE_O.NTAIL.n15 0.189974
R3700 XFE_O.NTAIL.n19 XFE_O.NTAIL.n17 0.189974
R3701 XFE_O.NTAIL.n21 XFE_O.NTAIL.n19 0.189974
R3702 XFE_O.NTAIL.n11 XFE_O.NTAIL.n9 0.189974
R3703 XFE_O.NTAIL.n9 XFE_O.NTAIL.n7 0.189974
R3704 XFE_O.NTAIL.n7 XFE_O.NTAIL.n5 0.189974
R3705 XFE_O.NTAIL.n5 XFE_O.NTAIL.n3 0.189974
R3706 XFE_O.NTAIL.n3 XFE_O.NTAIL.n1 0.189974
R3707 XFE_O.NTAIL.n28 XFE_O.NTAIL.n27 0.189974
R3708 XFE_O.NTAIL.n40 XFE_O.NTAIL.n39 0.189974
R3709 XFE_O.NTAIL.n0 XFE_O.NTAIL.t42 0.1643
R3710 XFE_O.NTAIL.n0 XFE_O.NTAIL.t43 0.1643
R3711 XFE_O.NTAIL.n30 XFE_O.NTAIL.t11 0.1643
R3712 XFE_O.NTAIL.n30 XFE_O.NTAIL.t12 0.1643
R3713 XFE_O.NTAIL.n31 XFE_O.NTAIL.t9 0.1643
R3714 XFE_O.NTAIL.n31 XFE_O.NTAIL.t10 0.1643
R3715 XFE_O.NTAIL.n2 XFE_O.NTAIL.t40 0.1643
R3716 XFE_O.NTAIL.n2 XFE_O.NTAIL.t41 0.1643
R3717 XFE_O.NTAIL.n4 XFE_O.NTAIL.t38 0.1643
R3718 XFE_O.NTAIL.n4 XFE_O.NTAIL.t39 0.1643
R3719 XFE_O.NTAIL.n6 XFE_O.NTAIL.t36 0.1643
R3720 XFE_O.NTAIL.n6 XFE_O.NTAIL.t37 0.1643
R3721 XFE_O.NTAIL.n8 XFE_O.NTAIL.t34 0.1643
R3722 XFE_O.NTAIL.n8 XFE_O.NTAIL.t35 0.1643
R3723 XFE_O.NTAIL.n10 XFE_O.NTAIL.t32 0.1643
R3724 XFE_O.NTAIL.n10 XFE_O.NTAIL.t33 0.1643
R3725 XFE_O.NTAIL.n20 XFE_O.NTAIL.t30 0.1643
R3726 XFE_O.NTAIL.n20 XFE_O.NTAIL.t31 0.1643
R3727 XFE_O.NTAIL.n18 XFE_O.NTAIL.t28 0.1643
R3728 XFE_O.NTAIL.n18 XFE_O.NTAIL.t29 0.1643
R3729 XFE_O.NTAIL.n16 XFE_O.NTAIL.t26 0.1643
R3730 XFE_O.NTAIL.n16 XFE_O.NTAIL.t27 0.1643
R3731 XFE_O.NTAIL.n14 XFE_O.NTAIL.t24 0.1643
R3732 XFE_O.NTAIL.n14 XFE_O.NTAIL.t25 0.1643
R3733 XFE_O.NTAIL.n12 XFE_O.NTAIL.t22 0.1643
R3734 XFE_O.NTAIL.n12 XFE_O.NTAIL.t23 0.1643
R3735 XFE_O.NTAIL.n22 XFE_O.NTAIL.n21 0.0952368
R3736 XFE_O.NTAIL.n22 XFE_O.NTAIL.n11 0.0952368
R3737 XFE_O.NTAIL.n33 XFE_O.NTAIL.n32 0.0478684
R3738 XFE_O.NTAIL XFE_O.NTAIL.n41 0.0396304
R3739 XFE_E.NTAIL.n35 XFE_E.NTAIL.n28 13.0309
R3740 XFE_E.NTAIL XFE_E.NTAIL.n5 11.544
R3741 XFE_E.NTAIL.n35 XFE_E.NTAIL.n34 11.5048
R3742 XFE_E.NTAIL.n40 XFE_E.NTAIL.n39 9.03963
R3743 XFE_E.NTAIL.n7 XFE_E.NTAIL.t31 5.82877
R3744 XFE_E.NTAIL.n17 XFE_E.NTAIL.t8 5.82877
R3745 XFE_E.NTAIL.n39 XFE_E.NTAIL.t44 5.78141
R3746 XFE_E.NTAIL.n38 XFE_E.NTAIL.n36 5.66497
R3747 XFE_E.NTAIL.n2 XFE_E.NTAIL.n0 5.57485
R3748 XFE_E.NTAIL.n5 XFE_E.NTAIL.n4 5.57485
R3749 XFE_E.NTAIL.n31 XFE_E.NTAIL.n29 5.57485
R3750 XFE_E.NTAIL.n34 XFE_E.NTAIL.n33 5.57485
R3751 XFE_E.NTAIL.n38 XFE_E.NTAIL.n37 5.4755
R3752 XFE_E.NTAIL.n7 XFE_E.NTAIL.n6 5.4755
R3753 XFE_E.NTAIL.n9 XFE_E.NTAIL.n8 5.4755
R3754 XFE_E.NTAIL.n11 XFE_E.NTAIL.n10 5.4755
R3755 XFE_E.NTAIL.n13 XFE_E.NTAIL.n12 5.4755
R3756 XFE_E.NTAIL.n15 XFE_E.NTAIL.n14 5.4755
R3757 XFE_E.NTAIL.n27 XFE_E.NTAIL.n26 5.4755
R3758 XFE_E.NTAIL.n25 XFE_E.NTAIL.n24 5.4755
R3759 XFE_E.NTAIL.n23 XFE_E.NTAIL.n22 5.4755
R3760 XFE_E.NTAIL.n21 XFE_E.NTAIL.n20 5.4755
R3761 XFE_E.NTAIL.n19 XFE_E.NTAIL.n18 5.4755
R3762 XFE_E.NTAIL.n17 XFE_E.NTAIL.n16 5.4755
R3763 XFE_E.NTAIL.n2 XFE_E.NTAIL.n1 5.38537
R3764 XFE_E.NTAIL.n5 XFE_E.NTAIL.n3 5.38537
R3765 XFE_E.NTAIL.n31 XFE_E.NTAIL.n30 5.38537
R3766 XFE_E.NTAIL.n34 XFE_E.NTAIL.n32 5.38537
R3767 XFE_E.NTAIL.n40 XFE_E.NTAIL.n35 2.27007
R3768 XFE_E.NTAIL XFE_E.NTAIL.n40 0.822239
R3769 XFE_E.NTAIL.n0 XFE_E.NTAIL.t2 0.20525
R3770 XFE_E.NTAIL.n0 XFE_E.NTAIL.t7 0.20525
R3771 XFE_E.NTAIL.n1 XFE_E.NTAIL.t0 0.20525
R3772 XFE_E.NTAIL.n1 XFE_E.NTAIL.t1 0.20525
R3773 XFE_E.NTAIL.n3 XFE_E.NTAIL.t5 0.20525
R3774 XFE_E.NTAIL.n3 XFE_E.NTAIL.t6 0.20525
R3775 XFE_E.NTAIL.n4 XFE_E.NTAIL.t3 0.20525
R3776 XFE_E.NTAIL.n4 XFE_E.NTAIL.t4 0.20525
R3777 XFE_E.NTAIL.n29 XFE_E.NTAIL.t38 0.20525
R3778 XFE_E.NTAIL.n29 XFE_E.NTAIL.t39 0.20525
R3779 XFE_E.NTAIL.n30 XFE_E.NTAIL.t33 0.20525
R3780 XFE_E.NTAIL.n30 XFE_E.NTAIL.t34 0.20525
R3781 XFE_E.NTAIL.n32 XFE_E.NTAIL.t37 0.20525
R3782 XFE_E.NTAIL.n32 XFE_E.NTAIL.t32 0.20525
R3783 XFE_E.NTAIL.n33 XFE_E.NTAIL.t35 0.20525
R3784 XFE_E.NTAIL.n33 XFE_E.NTAIL.t36 0.20525
R3785 XFE_E.NTAIL.n19 XFE_E.NTAIL.n17 0.189974
R3786 XFE_E.NTAIL.n21 XFE_E.NTAIL.n19 0.189974
R3787 XFE_E.NTAIL.n23 XFE_E.NTAIL.n21 0.189974
R3788 XFE_E.NTAIL.n25 XFE_E.NTAIL.n23 0.189974
R3789 XFE_E.NTAIL.n27 XFE_E.NTAIL.n25 0.189974
R3790 XFE_E.NTAIL.n15 XFE_E.NTAIL.n13 0.189974
R3791 XFE_E.NTAIL.n13 XFE_E.NTAIL.n11 0.189974
R3792 XFE_E.NTAIL.n11 XFE_E.NTAIL.n9 0.189974
R3793 XFE_E.NTAIL.n9 XFE_E.NTAIL.n7 0.189974
R3794 XFE_E.NTAIL.n5 XFE_E.NTAIL.n2 0.189974
R3795 XFE_E.NTAIL.n34 XFE_E.NTAIL.n31 0.189974
R3796 XFE_E.NTAIL.n37 XFE_E.NTAIL.t42 0.1643
R3797 XFE_E.NTAIL.n37 XFE_E.NTAIL.t43 0.1643
R3798 XFE_E.NTAIL.n36 XFE_E.NTAIL.t40 0.1643
R3799 XFE_E.NTAIL.n36 XFE_E.NTAIL.t41 0.1643
R3800 XFE_E.NTAIL.n6 XFE_E.NTAIL.t29 0.1643
R3801 XFE_E.NTAIL.n6 XFE_E.NTAIL.t30 0.1643
R3802 XFE_E.NTAIL.n8 XFE_E.NTAIL.t27 0.1643
R3803 XFE_E.NTAIL.n8 XFE_E.NTAIL.t28 0.1643
R3804 XFE_E.NTAIL.n10 XFE_E.NTAIL.t25 0.1643
R3805 XFE_E.NTAIL.n10 XFE_E.NTAIL.t26 0.1643
R3806 XFE_E.NTAIL.n12 XFE_E.NTAIL.t23 0.1643
R3807 XFE_E.NTAIL.n12 XFE_E.NTAIL.t24 0.1643
R3808 XFE_E.NTAIL.n14 XFE_E.NTAIL.t21 0.1643
R3809 XFE_E.NTAIL.n14 XFE_E.NTAIL.t22 0.1643
R3810 XFE_E.NTAIL.n26 XFE_E.NTAIL.t19 0.1643
R3811 XFE_E.NTAIL.n26 XFE_E.NTAIL.t20 0.1643
R3812 XFE_E.NTAIL.n24 XFE_E.NTAIL.t17 0.1643
R3813 XFE_E.NTAIL.n24 XFE_E.NTAIL.t18 0.1643
R3814 XFE_E.NTAIL.n22 XFE_E.NTAIL.t15 0.1643
R3815 XFE_E.NTAIL.n22 XFE_E.NTAIL.t16 0.1643
R3816 XFE_E.NTAIL.n20 XFE_E.NTAIL.t13 0.1643
R3817 XFE_E.NTAIL.n20 XFE_E.NTAIL.t14 0.1643
R3818 XFE_E.NTAIL.n18 XFE_E.NTAIL.t11 0.1643
R3819 XFE_E.NTAIL.n18 XFE_E.NTAIL.t12 0.1643
R3820 XFE_E.NTAIL.n16 XFE_E.NTAIL.t9 0.1643
R3821 XFE_E.NTAIL.n16 XFE_E.NTAIL.t10 0.1643
R3822 XFE_E.NTAIL.n28 XFE_E.NTAIL.n27 0.0952368
R3823 XFE_E.NTAIL.n28 XFE_E.NTAIL.n15 0.0952368
R3824 XFE_E.NTAIL.n39 XFE_E.NTAIL.n38 0.0478684
R3825 XFE_O.DN.t13 XFE_O.DN.n10 127.788
R3826 XFE_O.DN.t6 XFE_O.DN.n0 127.776
R3827 XFE_O.DN.n10 XFE_O.DN.t12 127.668
R3828 XFE_O.DN.n9 XFE_O.DN.t11 127.668
R3829 XFE_O.DN.n8 XFE_O.DN.t10 127.668
R3830 XFE_O.DN.n7 XFE_O.DN.t9 127.668
R3831 XFE_O.DN.n6 XFE_O.DN.t8 127.668
R3832 XFE_O.DN.t7 XFE_O.DN.n0 127.668
R3833 XFE_O.DN.n11 XFE_O.DN.t13 113.632
R3834 XFE_O.DN.n1 XFE_O.DN.t6 113.629
R3835 XFE_O.DN.t12 XFE_O.DN.n5 109.174
R3836 XFE_O.DN.n13 XFE_O.DN.t11 109.174
R3837 XFE_O.DN.n14 XFE_O.DN.t10 109.174
R3838 XFE_O.DN.n15 XFE_O.DN.t9 109.174
R3839 XFE_O.DN.n16 XFE_O.DN.t8 109.174
R3840 XFE_O.DN.n3 XFE_O.DN.t7 109.174
R3841 XFE_O.DN.n13 XFE_O.DN.n12 18.4942
R3842 XFE_O.DN.n14 XFE_O.DN.n4 18.4942
R3843 XFE_O.DN.n15 XFE_O.DN.n2 18.4942
R3844 XFE_O.DN.n17 XFE_O.DN.n16 18.4942
R3845 XFE_O.DN.n23 XFE_O.DN.n22 14.1606
R3846 XFE_O.DN.n14 XFE_O.DN.n13 11.6805
R3847 XFE_O.DN.n13 XFE_O.DN.n5 11.6805
R3848 XFE_O.DN.n15 XFE_O.DN.n14 11.6805
R3849 XFE_O.DN.n16 XFE_O.DN.n15 11.6805
R3850 XFE_O.DN.n16 XFE_O.DN.n3 11.6805
R3851 XFE_O.DN.n19 XFE_O.DN.n0 10.8201
R3852 XFE_O.DN.n25 XFE_O.DN.n24 10.5266
R3853 XFE_O.DN.n19 XFE_O.DN.n18 9.02007
R3854 XFE_O.DN.n23 XFE_O.DN.n19 7.2005
R3855 XFE_O.DN.n12 XFE_O.DN.n11 7.17687
R3856 XFE_O.DN.n18 XFE_O.DN.n1 7.05405
R3857 XFE_O.DN.n24 XFE_O.DN.t3 5.7796
R3858 XFE_O.DN.n21 XFE_O.DN.t2 5.73764
R3859 XFE_O.DN.n24 XFE_O.DN.t0 5.59012
R3860 XFE_O.DN.n22 XFE_O.DN.t1 5.54817
R3861 XFE_O.DN.n21 XFE_O.DN.n20 5.32067
R3862 XFE_O.DN.n3 XFE_O.DN.n1 4.4296
R3863 XFE_O.DN.n11 XFE_O.DN.n5 4.42851
R3864 XFE_O.DN.n25 XFE_O.DN.n23 0.978761
R3865 XFE_O.DN.n20 XFE_O.DN.t5 0.228
R3866 XFE_O.DN.n20 XFE_O.DN.t4 0.228
R3867 XFE_O.DN.n22 XFE_O.DN.n21 0.189974
R3868 XFE_O.DN.n10 XFE_O.DN.n9 0.1205
R3869 XFE_O.DN.n9 XFE_O.DN.n8 0.1205
R3870 XFE_O.DN.n8 XFE_O.DN.n7 0.1205
R3871 XFE_O.DN.n7 XFE_O.DN.n6 0.1205
R3872 XFE_O.DN.n12 XFE_O.DN.n4 0.1205
R3873 XFE_O.DN.n4 XFE_O.DN.n2 0.1205
R3874 XFE_O.DN.n17 XFE_O.DN.n2 0.1205
R3875 XFE_O.DN.n6 XFE_O.DN.n0 0.1085
R3876 XFE_O.DN.n18 XFE_O.DN.n17 0.1085
R3877 XFE_O.DN XFE_O.DN.n25 0.0396304
R3878 XFE_O.DP.t13 XFE_O.DP.n15 127.788
R3879 XFE_O.DP.t6 XFE_O.DP.n5 127.776
R3880 XFE_O.DP.n15 XFE_O.DP.t12 127.668
R3881 XFE_O.DP.n14 XFE_O.DP.t11 127.668
R3882 XFE_O.DP.n13 XFE_O.DP.t10 127.668
R3883 XFE_O.DP.n12 XFE_O.DP.t9 127.668
R3884 XFE_O.DP.n11 XFE_O.DP.t8 127.668
R3885 XFE_O.DP.t7 XFE_O.DP.n5 127.668
R3886 XFE_O.DP.n16 XFE_O.DP.t13 113.632
R3887 XFE_O.DP.n6 XFE_O.DP.t6 113.629
R3888 XFE_O.DP.t12 XFE_O.DP.n10 109.174
R3889 XFE_O.DP.n18 XFE_O.DP.t11 109.174
R3890 XFE_O.DP.n19 XFE_O.DP.t10 109.174
R3891 XFE_O.DP.n20 XFE_O.DP.t9 109.174
R3892 XFE_O.DP.n21 XFE_O.DP.t8 109.174
R3893 XFE_O.DP.n8 XFE_O.DP.t7 109.174
R3894 XFE_O.DP.n18 XFE_O.DP.n17 18.4942
R3895 XFE_O.DP.n19 XFE_O.DP.n9 18.4942
R3896 XFE_O.DP.n20 XFE_O.DP.n7 18.4942
R3897 XFE_O.DP.n22 XFE_O.DP.n21 18.4942
R3898 XFE_O.DP.n4 XFE_O.DP.n3 14.5055
R3899 XFE_O.DP.n4 XFE_O.DP.n0 11.7788
R3900 XFE_O.DP.n19 XFE_O.DP.n18 11.6805
R3901 XFE_O.DP.n18 XFE_O.DP.n10 11.6805
R3902 XFE_O.DP.n20 XFE_O.DP.n19 11.6805
R3903 XFE_O.DP.n21 XFE_O.DP.n20 11.6805
R3904 XFE_O.DP.n21 XFE_O.DP.n8 11.6805
R3905 XFE_O.DP.n24 XFE_O.DP.n5 10.8396
R3906 XFE_O.DP.n24 XFE_O.DP.n23 9.0005
R3907 XFE_O.DP.n17 XFE_O.DP.n16 7.17687
R3908 XFE_O.DP.n23 XFE_O.DP.n6 7.05405
R3909 XFE_O.DP.n2 XFE_O.DP.t2 5.73764
R3910 XFE_O.DP.n0 XFE_O.DP.t5 5.70855
R3911 XFE_O.DP.n0 XFE_O.DP.t4 5.66118
R3912 XFE_O.DP.n3 XFE_O.DP.t1 5.54817
R3913 XFE_O.DP.n2 XFE_O.DP.n1 5.32067
R3914 XFE_O.DP.n25 XFE_O.DP.n24 4.75485
R3915 XFE_O.DP.n8 XFE_O.DP.n6 4.4296
R3916 XFE_O.DP.n16 XFE_O.DP.n10 4.42851
R3917 XFE_O.DP.n25 XFE_O.DP.n4 1.8005
R3918 XFE_O.DP.n1 XFE_O.DP.t0 0.228
R3919 XFE_O.DP.n1 XFE_O.DP.t3 0.228
R3920 XFE_O.DP.n3 XFE_O.DP.n2 0.189974
R3921 XFE_O.DP.n15 XFE_O.DP.n14 0.1205
R3922 XFE_O.DP.n14 XFE_O.DP.n13 0.1205
R3923 XFE_O.DP.n13 XFE_O.DP.n12 0.1205
R3924 XFE_O.DP.n12 XFE_O.DP.n11 0.1205
R3925 XFE_O.DP.n17 XFE_O.DP.n9 0.1205
R3926 XFE_O.DP.n9 XFE_O.DP.n7 0.1205
R3927 XFE_O.DP.n22 XFE_O.DP.n7 0.1205
R3928 XFE_O.DP.n11 XFE_O.DP.n5 0.1085
R3929 XFE_O.DP.n23 XFE_O.DP.n22 0.1085
R3930 XFE_O.DP XFE_O.DP.n25 0.0396304
R3931 XFE_E.DP.t6 XFE_E.DP.n7 127.788
R3932 XFE_E.DP.t13 XFE_E.DP.n0 127.776
R3933 XFE_E.DP.t11 XFE_E.DP.n14 127.668
R3934 XFE_E.DP.t12 XFE_E.DP.n0 127.668
R3935 XFE_E.DP.n7 XFE_E.DP.t7 127.668
R3936 XFE_E.DP.t8 XFE_E.DP.n3 127.668
R3937 XFE_E.DP.n12 XFE_E.DP.t9 127.668
R3938 XFE_E.DP.n13 XFE_E.DP.t10 127.668
R3939 XFE_E.DP.n8 XFE_E.DP.t6 113.632
R3940 XFE_E.DP.n17 XFE_E.DP.t13 113.629
R3941 XFE_E.DP.n15 XFE_E.DP.t11 109.174
R3942 XFE_E.DP.n16 XFE_E.DP.t12 109.174
R3943 XFE_E.DP.n9 XFE_E.DP.t7 109.174
R3944 XFE_E.DP.n10 XFE_E.DP.t8 109.174
R3945 XFE_E.DP.t9 XFE_E.DP.n11 109.174
R3946 XFE_E.DP.t10 XFE_E.DP.n2 109.174
R3947 XFE_E.DP.n15 XFE_E.DP.n1 18.4942
R3948 XFE_E.DP.n10 XFE_E.DP.n6 18.4942
R3949 XFE_E.DP.n11 XFE_E.DP.n5 18.4942
R3950 XFE_E.DP.n4 XFE_E.DP.n2 18.4942
R3951 XFE_E.DP.n24 XFE_E.DP.n23 14.5055
R3952 XFE_E.DP.n24 XFE_E.DP.n20 11.7788
R3953 XFE_E.DP.n16 XFE_E.DP.n15 11.6805
R3954 XFE_E.DP.n10 XFE_E.DP.n9 11.6805
R3955 XFE_E.DP.n11 XFE_E.DP.n10 11.6805
R3956 XFE_E.DP.n11 XFE_E.DP.n2 11.6805
R3957 XFE_E.DP.n15 XFE_E.DP.n2 11.6805
R3958 XFE_E.DP.n19 XFE_E.DP.n0 10.8396
R3959 XFE_E.DP.n19 XFE_E.DP.n18 9.0005
R3960 XFE_E.DP.n8 XFE_E.DP.n6 7.17687
R3961 XFE_E.DP.n18 XFE_E.DP.n17 7.05405
R3962 XFE_E.DP.n22 XFE_E.DP.t5 5.73764
R3963 XFE_E.DP.n20 XFE_E.DP.t4 5.70855
R3964 XFE_E.DP.n20 XFE_E.DP.t0 5.66118
R3965 XFE_E.DP.n23 XFE_E.DP.t1 5.54817
R3966 XFE_E.DP.n22 XFE_E.DP.n21 5.32067
R3967 XFE_E.DP XFE_E.DP.n19 4.79398
R3968 XFE_E.DP.n17 XFE_E.DP.n16 4.4296
R3969 XFE_E.DP.n9 XFE_E.DP.n8 4.42851
R3970 XFE_E.DP XFE_E.DP.n24 1.76137
R3971 XFE_E.DP.n21 XFE_E.DP.t3 0.228
R3972 XFE_E.DP.n21 XFE_E.DP.t2 0.228
R3973 XFE_E.DP.n23 XFE_E.DP.n22 0.189974
R3974 XFE_E.DP.n4 XFE_E.DP.n1 0.1205
R3975 XFE_E.DP.n5 XFE_E.DP.n4 0.1205
R3976 XFE_E.DP.n6 XFE_E.DP.n5 0.1205
R3977 XFE_E.DP.n14 XFE_E.DP.n13 0.1205
R3978 XFE_E.DP.n13 XFE_E.DP.n12 0.1205
R3979 XFE_E.DP.n12 XFE_E.DP.n3 0.1205
R3980 XFE_E.DP.n7 XFE_E.DP.n3 0.1205
R3981 XFE_E.DP.n18 XFE_E.DP.n1 0.1085
R3982 XFE_E.DP.n14 XFE_E.DP.n0 0.1085
R3983 XFE_E.DN.t6 XFE_E.DN.n8 127.788
R3984 XFE_E.DN.t13 XFE_E.DN.n1 127.776
R3985 XFE_E.DN.t11 XFE_E.DN.n15 127.668
R3986 XFE_E.DN.t12 XFE_E.DN.n1 127.668
R3987 XFE_E.DN.n8 XFE_E.DN.t7 127.668
R3988 XFE_E.DN.t8 XFE_E.DN.n4 127.668
R3989 XFE_E.DN.n13 XFE_E.DN.t9 127.668
R3990 XFE_E.DN.n14 XFE_E.DN.t10 127.668
R3991 XFE_E.DN.n9 XFE_E.DN.t6 113.632
R3992 XFE_E.DN.n18 XFE_E.DN.t13 113.629
R3993 XFE_E.DN.n16 XFE_E.DN.t11 109.174
R3994 XFE_E.DN.n17 XFE_E.DN.t12 109.174
R3995 XFE_E.DN.n10 XFE_E.DN.t7 109.174
R3996 XFE_E.DN.n11 XFE_E.DN.t8 109.174
R3997 XFE_E.DN.t9 XFE_E.DN.n12 109.174
R3998 XFE_E.DN.t10 XFE_E.DN.n3 109.174
R3999 XFE_E.DN.n16 XFE_E.DN.n2 18.4942
R4000 XFE_E.DN.n11 XFE_E.DN.n7 18.4942
R4001 XFE_E.DN.n12 XFE_E.DN.n6 18.4942
R4002 XFE_E.DN.n5 XFE_E.DN.n3 18.4942
R4003 XFE_E.DN.n24 XFE_E.DN.n23 14.1606
R4004 XFE_E.DN.n17 XFE_E.DN.n16 11.6805
R4005 XFE_E.DN.n11 XFE_E.DN.n10 11.6805
R4006 XFE_E.DN.n12 XFE_E.DN.n11 11.6805
R4007 XFE_E.DN.n12 XFE_E.DN.n3 11.6805
R4008 XFE_E.DN.n16 XFE_E.DN.n3 11.6805
R4009 XFE_E.DN.n20 XFE_E.DN.n1 10.8201
R4010 XFE_E.DN XFE_E.DN.n0 10.5657
R4011 XFE_E.DN.n20 XFE_E.DN.n19 9.02007
R4012 XFE_E.DN.n24 XFE_E.DN.n20 7.2005
R4013 XFE_E.DN.n9 XFE_E.DN.n7 7.17687
R4014 XFE_E.DN.n19 XFE_E.DN.n18 7.05405
R4015 XFE_E.DN.n0 XFE_E.DN.t4 5.7796
R4016 XFE_E.DN.n22 XFE_E.DN.t5 5.73764
R4017 XFE_E.DN.n0 XFE_E.DN.t1 5.59012
R4018 XFE_E.DN.n23 XFE_E.DN.t3 5.54817
R4019 XFE_E.DN.n22 XFE_E.DN.n21 5.32067
R4020 XFE_E.DN.n18 XFE_E.DN.n17 4.4296
R4021 XFE_E.DN.n10 XFE_E.DN.n9 4.42851
R4022 XFE_E.DN XFE_E.DN.n24 0.93963
R4023 XFE_E.DN.n21 XFE_E.DN.t0 0.228
R4024 XFE_E.DN.n21 XFE_E.DN.t2 0.228
R4025 XFE_E.DN.n23 XFE_E.DN.n22 0.189974
R4026 XFE_E.DN.n5 XFE_E.DN.n2 0.1205
R4027 XFE_E.DN.n6 XFE_E.DN.n5 0.1205
R4028 XFE_E.DN.n7 XFE_E.DN.n6 0.1205
R4029 XFE_E.DN.n15 XFE_E.DN.n14 0.1205
R4030 XFE_E.DN.n14 XFE_E.DN.n13 0.1205
R4031 XFE_E.DN.n13 XFE_E.DN.n4 0.1205
R4032 XFE_E.DN.n8 XFE_E.DN.n4 0.1205
R4033 XFE_E.DN.n19 XFE_E.DN.n2 0.1085
R4034 XFE_E.DN.n15 XFE_E.DN.n1 0.1085
R4035 XFE_O.NIN.n13 XFE_O.NIN.n12 19.957
R4036 XFE_O.NIN.n13 XFE_O.NIN.n9 12.3657
R4037 XFE_O.NIN.n21 XFE_O.NIN.n20 11.9353
R4038 XFE_O.NIN.n15 XFE_O.NIN.t15 5.7796
R4039 XFE_O.NIN.n19 XFE_O.NIN.t8 5.7796
R4040 XFE_O.NIN.n11 XFE_O.NIN.t21 5.73764
R4041 XFE_O.NIN.n12 XFE_O.NIN.t18 5.6429
R4042 XFE_O.NIN.n2 XFE_O.NIN.n0 5.57485
R4043 XFE_O.NIN.n6 XFE_O.NIN.n4 5.57485
R4044 XFE_O.NIN.n2 XFE_O.NIN.n1 5.38537
R4045 XFE_O.NIN.n9 XFE_O.NIN.n3 5.38537
R4046 XFE_O.NIN.n8 XFE_O.NIN.n7 5.38537
R4047 XFE_O.NIN.n6 XFE_O.NIN.n5 5.38537
R4048 XFE_O.NIN.n15 XFE_O.NIN.n14 5.38537
R4049 XFE_O.NIN.n17 XFE_O.NIN.n16 5.38537
R4050 XFE_O.NIN.n19 XFE_O.NIN.n18 5.38537
R4051 XFE_O.NIN.n11 XFE_O.NIN.n10 5.32067
R4052 XFE_O.NIN.n21 XFE_O.NIN.n13 1.95702
R4053 XFE_O.NIN.n10 XFE_O.NIN.t19 0.228
R4054 XFE_O.NIN.n10 XFE_O.NIN.t20 0.228
R4055 XFE_O.NIN.n0 XFE_O.NIN.t3 0.20525
R4056 XFE_O.NIN.n0 XFE_O.NIN.t2 0.20525
R4057 XFE_O.NIN.n1 XFE_O.NIN.t5 0.20525
R4058 XFE_O.NIN.n1 XFE_O.NIN.t4 0.20525
R4059 XFE_O.NIN.n3 XFE_O.NIN.t7 0.20525
R4060 XFE_O.NIN.n3 XFE_O.NIN.t6 0.20525
R4061 XFE_O.NIN.n7 XFE_O.NIN.t1 0.20525
R4062 XFE_O.NIN.n7 XFE_O.NIN.t0 0.20525
R4063 XFE_O.NIN.n5 XFE_O.NIN.t17 0.20525
R4064 XFE_O.NIN.n5 XFE_O.NIN.t16 0.20525
R4065 XFE_O.NIN.n4 XFE_O.NIN.t23 0.20525
R4066 XFE_O.NIN.n4 XFE_O.NIN.t22 0.20525
R4067 XFE_O.NIN.n14 XFE_O.NIN.t13 0.20525
R4068 XFE_O.NIN.n14 XFE_O.NIN.t14 0.20525
R4069 XFE_O.NIN.n16 XFE_O.NIN.t11 0.20525
R4070 XFE_O.NIN.n16 XFE_O.NIN.t12 0.20525
R4071 XFE_O.NIN.n18 XFE_O.NIN.t9 0.20525
R4072 XFE_O.NIN.n18 XFE_O.NIN.t10 0.20525
R4073 XFE_O.NIN.n17 XFE_O.NIN.n15 0.189974
R4074 XFE_O.NIN.n8 XFE_O.NIN.n6 0.189974
R4075 XFE_O.NIN.n9 XFE_O.NIN.n8 0.189974
R4076 XFE_O.NIN.n9 XFE_O.NIN.n2 0.189974
R4077 XFE_O.NIN.n20 XFE_O.NIN.n19 0.0952368
R4078 XFE_O.NIN.n20 XFE_O.NIN.n17 0.0952368
R4079 XFE_O.NIN.n12 XFE_O.NIN.n11 0.0952368
R4080 XFE_O.NIN XFE_O.NIN.n21 0.0396304
R4081 XFE_O.NIP.n10 XFE_O.NIP.n9 20.2309
R4082 XFE_O.NIP.n10 XFE_O.NIP.n6 14.1657
R4083 XFE_O.NIP.n21 XFE_O.NIP.n20 10.957
R4084 XFE_O.NIP.n1 XFE_O.NIP.t23 5.7796
R4085 XFE_O.NIP.n5 XFE_O.NIP.t16 5.7796
R4086 XFE_O.NIP.n8 XFE_O.NIP.t15 5.73764
R4087 XFE_O.NIP.n9 XFE_O.NIP.t12 5.6429
R4088 XFE_O.NIP.n13 XFE_O.NIP.n11 5.57485
R4089 XFE_O.NIP.n17 XFE_O.NIP.n15 5.57485
R4090 XFE_O.NIP.n1 XFE_O.NIP.n0 5.38537
R4091 XFE_O.NIP.n13 XFE_O.NIP.n12 5.38537
R4092 XFE_O.NIP.n20 XFE_O.NIP.n14 5.38537
R4093 XFE_O.NIP.n19 XFE_O.NIP.n18 5.38537
R4094 XFE_O.NIP.n17 XFE_O.NIP.n16 5.38537
R4095 XFE_O.NIP.n3 XFE_O.NIP.n2 5.38537
R4096 XFE_O.NIP.n5 XFE_O.NIP.n4 5.38537
R4097 XFE_O.NIP.n8 XFE_O.NIP.n7 5.32067
R4098 XFE_O.NIP.n21 XFE_O.NIP.n10 1.05702
R4099 XFE_O.NIP.n7 XFE_O.NIP.t13 0.228
R4100 XFE_O.NIP.n7 XFE_O.NIP.t14 0.228
R4101 XFE_O.NIP.n0 XFE_O.NIP.t21 0.20525
R4102 XFE_O.NIP.n0 XFE_O.NIP.t22 0.20525
R4103 XFE_O.NIP.n11 XFE_O.NIP.t8 0.20525
R4104 XFE_O.NIP.n11 XFE_O.NIP.t6 0.20525
R4105 XFE_O.NIP.n12 XFE_O.NIP.t0 0.20525
R4106 XFE_O.NIP.n12 XFE_O.NIP.t9 0.20525
R4107 XFE_O.NIP.n14 XFE_O.NIP.t10 0.20525
R4108 XFE_O.NIP.n14 XFE_O.NIP.t1 0.20525
R4109 XFE_O.NIP.n18 XFE_O.NIP.t2 0.20525
R4110 XFE_O.NIP.n18 XFE_O.NIP.t11 0.20525
R4111 XFE_O.NIP.n16 XFE_O.NIP.t4 0.20525
R4112 XFE_O.NIP.n16 XFE_O.NIP.t3 0.20525
R4113 XFE_O.NIP.n15 XFE_O.NIP.t7 0.20525
R4114 XFE_O.NIP.n15 XFE_O.NIP.t5 0.20525
R4115 XFE_O.NIP.n2 XFE_O.NIP.t19 0.20525
R4116 XFE_O.NIP.n2 XFE_O.NIP.t20 0.20525
R4117 XFE_O.NIP.n4 XFE_O.NIP.t17 0.20525
R4118 XFE_O.NIP.n4 XFE_O.NIP.t18 0.20525
R4119 XFE_O.NIP.n3 XFE_O.NIP.n1 0.189974
R4120 XFE_O.NIP.n19 XFE_O.NIP.n17 0.189974
R4121 XFE_O.NIP.n20 XFE_O.NIP.n19 0.189974
R4122 XFE_O.NIP.n20 XFE_O.NIP.n13 0.189974
R4123 XFE_O.NIP.n6 XFE_O.NIP.n5 0.0952368
R4124 XFE_O.NIP.n6 XFE_O.NIP.n3 0.0952368
R4125 XFE_O.NIP.n9 XFE_O.NIP.n8 0.0952368
R4126 XFE_O.NIP XFE_O.NIP.n21 0.0396304
R4127 XFE_E.NIP.n20 XFE_E.NIP.n19 20.2309
R4128 XFE_E.NIP.n20 XFE_E.NIP.n16 14.1657
R4129 XFE_E.NIP XFE_E.NIP.n9 10.9962
R4130 XFE_E.NIP.n11 XFE_E.NIP.t13 5.7796
R4131 XFE_E.NIP.n13 XFE_E.NIP.t6 5.7796
R4132 XFE_E.NIP.n18 XFE_E.NIP.t20 5.73764
R4133 XFE_E.NIP.n19 XFE_E.NIP.t23 5.6429
R4134 XFE_E.NIP.n2 XFE_E.NIP.n0 5.57485
R4135 XFE_E.NIP.n8 XFE_E.NIP.n6 5.57485
R4136 XFE_E.NIP.n2 XFE_E.NIP.n1 5.38537
R4137 XFE_E.NIP.n4 XFE_E.NIP.n3 5.38537
R4138 XFE_E.NIP.n9 XFE_E.NIP.n5 5.38537
R4139 XFE_E.NIP.n8 XFE_E.NIP.n7 5.38537
R4140 XFE_E.NIP.n11 XFE_E.NIP.n10 5.38537
R4141 XFE_E.NIP.n15 XFE_E.NIP.n14 5.38537
R4142 XFE_E.NIP.n13 XFE_E.NIP.n12 5.38537
R4143 XFE_E.NIP.n18 XFE_E.NIP.n17 5.32067
R4144 XFE_E.NIP XFE_E.NIP.n20 1.01789
R4145 XFE_E.NIP.n17 XFE_E.NIP.t21 0.228
R4146 XFE_E.NIP.n17 XFE_E.NIP.t22 0.228
R4147 XFE_E.NIP.n0 XFE_E.NIP.t3 0.20525
R4148 XFE_E.NIP.n0 XFE_E.NIP.t2 0.20525
R4149 XFE_E.NIP.n1 XFE_E.NIP.t15 0.20525
R4150 XFE_E.NIP.n1 XFE_E.NIP.t14 0.20525
R4151 XFE_E.NIP.n3 XFE_E.NIP.t19 0.20525
R4152 XFE_E.NIP.n3 XFE_E.NIP.t18 0.20525
R4153 XFE_E.NIP.n5 XFE_E.NIP.t17 0.20525
R4154 XFE_E.NIP.n5 XFE_E.NIP.t16 0.20525
R4155 XFE_E.NIP.n7 XFE_E.NIP.t5 0.20525
R4156 XFE_E.NIP.n7 XFE_E.NIP.t4 0.20525
R4157 XFE_E.NIP.n6 XFE_E.NIP.t1 0.20525
R4158 XFE_E.NIP.n6 XFE_E.NIP.t0 0.20525
R4159 XFE_E.NIP.n10 XFE_E.NIP.t11 0.20525
R4160 XFE_E.NIP.n10 XFE_E.NIP.t12 0.20525
R4161 XFE_E.NIP.n14 XFE_E.NIP.t9 0.20525
R4162 XFE_E.NIP.n14 XFE_E.NIP.t10 0.20525
R4163 XFE_E.NIP.n12 XFE_E.NIP.t7 0.20525
R4164 XFE_E.NIP.n12 XFE_E.NIP.t8 0.20525
R4165 XFE_E.NIP.n15 XFE_E.NIP.n13 0.189974
R4166 XFE_E.NIP.n9 XFE_E.NIP.n8 0.189974
R4167 XFE_E.NIP.n9 XFE_E.NIP.n4 0.189974
R4168 XFE_E.NIP.n4 XFE_E.NIP.n2 0.189974
R4169 XFE_E.NIP.n16 XFE_E.NIP.n15 0.0952368
R4170 XFE_E.NIP.n16 XFE_E.NIP.n11 0.0952368
R4171 XFE_E.NIP.n19 XFE_E.NIP.n18 0.0952368
R4172 XFE_E.NIN.n20 XFE_E.NIN.n19 19.957
R4173 XFE_E.NIN.n20 XFE_E.NIN.n16 12.3657
R4174 XFE_E.NIN XFE_E.NIN.n6 11.9744
R4175 XFE_E.NIN.n1 XFE_E.NIN.t19 5.7796
R4176 XFE_E.NIN.n3 XFE_E.NIN.t12 5.7796
R4177 XFE_E.NIN.n18 XFE_E.NIN.t20 5.73764
R4178 XFE_E.NIN.n19 XFE_E.NIN.t23 5.6429
R4179 XFE_E.NIN.n9 XFE_E.NIN.n7 5.57485
R4180 XFE_E.NIN.n15 XFE_E.NIN.n13 5.57485
R4181 XFE_E.NIN.n9 XFE_E.NIN.n8 5.38537
R4182 XFE_E.NIN.n11 XFE_E.NIN.n10 5.38537
R4183 XFE_E.NIN.n16 XFE_E.NIN.n12 5.38537
R4184 XFE_E.NIN.n15 XFE_E.NIN.n14 5.38537
R4185 XFE_E.NIN.n1 XFE_E.NIN.n0 5.38537
R4186 XFE_E.NIN.n5 XFE_E.NIN.n4 5.38537
R4187 XFE_E.NIN.n3 XFE_E.NIN.n2 5.38537
R4188 XFE_E.NIN.n18 XFE_E.NIN.n17 5.32067
R4189 XFE_E.NIN XFE_E.NIN.n20 1.91789
R4190 XFE_E.NIN.n17 XFE_E.NIN.t21 0.228
R4191 XFE_E.NIN.n17 XFE_E.NIN.t22 0.228
R4192 XFE_E.NIN.n7 XFE_E.NIN.t10 0.20525
R4193 XFE_E.NIN.n7 XFE_E.NIN.t8 0.20525
R4194 XFE_E.NIN.n8 XFE_E.NIN.t6 0.20525
R4195 XFE_E.NIN.n8 XFE_E.NIN.t11 0.20525
R4196 XFE_E.NIN.n10 XFE_E.NIN.t0 0.20525
R4197 XFE_E.NIN.n10 XFE_E.NIN.t7 0.20525
R4198 XFE_E.NIN.n12 XFE_E.NIN.t2 0.20525
R4199 XFE_E.NIN.n12 XFE_E.NIN.t1 0.20525
R4200 XFE_E.NIN.n14 XFE_E.NIN.t4 0.20525
R4201 XFE_E.NIN.n14 XFE_E.NIN.t3 0.20525
R4202 XFE_E.NIN.n13 XFE_E.NIN.t9 0.20525
R4203 XFE_E.NIN.n13 XFE_E.NIN.t5 0.20525
R4204 XFE_E.NIN.n0 XFE_E.NIN.t17 0.20525
R4205 XFE_E.NIN.n0 XFE_E.NIN.t18 0.20525
R4206 XFE_E.NIN.n4 XFE_E.NIN.t15 0.20525
R4207 XFE_E.NIN.n4 XFE_E.NIN.t16 0.20525
R4208 XFE_E.NIN.n2 XFE_E.NIN.t13 0.20525
R4209 XFE_E.NIN.n2 XFE_E.NIN.t14 0.20525
R4210 XFE_E.NIN.n5 XFE_E.NIN.n3 0.189974
R4211 XFE_E.NIN.n16 XFE_E.NIN.n15 0.189974
R4212 XFE_E.NIN.n16 XFE_E.NIN.n11 0.189974
R4213 XFE_E.NIN.n11 XFE_E.NIN.n9 0.189974
R4214 XFE_E.NIN.n6 XFE_E.NIN.n5 0.0952368
R4215 XFE_E.NIN.n6 XFE_E.NIN.n1 0.0952368
R4216 XFE_E.NIN.n19 XFE_E.NIN.n18 0.0952368
R4217 XFE_O.HB.n28 XFE_O.HB.t21 142.571
R4218 XFE_O.HB.n5 XFE_O.HB.t17 113.632
R4219 XFE_O.HB.n0 XFE_O.HB.t24 113.632
R4220 XFE_O.HB.n30 XFE_O.HB.t25 113.632
R4221 XFE_O.HB.n7 XFE_O.HB.t19 109.174
R4222 XFE_O.HB.n8 XFE_O.HB.t20 109.174
R4223 XFE_O.HB.n6 XFE_O.HB.t18 109.174
R4224 XFE_O.HB.n1 XFE_O.HB.t23 109.174
R4225 XFE_O.HB.n2 XFE_O.HB.t22 109.174
R4226 XFE_O.HB.n33 XFE_O.HB.t28 109.174
R4227 XFE_O.HB.n32 XFE_O.HB.t27 109.174
R4228 XFE_O.HB.n31 XFE_O.HB.t26 109.174
R4229 XFE_O.HB.n9 XFE_O.HB.n8 18.5179
R4230 XFE_O.HB.n7 XFE_O.HB.n4 18.4942
R4231 XFE_O.HB.n3 XFE_O.HB.n2 18.4942
R4232 XFE_O.HB.n34 XFE_O.HB.n33 18.4942
R4233 XFE_O.HB.n32 XFE_O.HB.n29 18.4942
R4234 XFE_O.HB.n27 XFE_O.HB.n26 17.4527
R4235 XFE_O.HB.n10 XFE_O.HB.n3 16.4663
R4236 XFE_O.HB.n35 XFE_O.HB.n34 15.8194
R4237 XFE_O.HB.n23 XFE_O.HB.t2 15.1863
R4238 XFE_O.HB.n10 XFE_O.HB.n9 14.6157
R4239 XFE_O.HB.n28 XFE_O.HB.n27 13.344
R4240 XFE_O.HB.n22 XFE_O.HB.n21 12.757
R4241 XFE_O.HB.n7 XFE_O.HB.n6 11.6805
R4242 XFE_O.HB.n8 XFE_O.HB.n7 11.6805
R4243 XFE_O.HB.n2 XFE_O.HB.n1 11.6805
R4244 XFE_O.HB.n33 XFE_O.HB.n32 11.6805
R4245 XFE_O.HB.n32 XFE_O.HB.n31 11.6805
R4246 XFE_O.HB.n18 XFE_O.HB.n17 9.43093
R4247 XFE_O.HB.n5 XFE_O.HB.n4 7.17687
R4248 XFE_O.HB.n3 XFE_O.HB.n0 7.17687
R4249 XFE_O.HB.n30 XFE_O.HB.n29 7.17687
R4250 XFE_O.HB.n12 XFE_O.HB.t12 5.7796
R4251 XFE_O.HB.n16 XFE_O.HB.t5 5.7796
R4252 XFE_O.HB.n20 XFE_O.HB.t3 5.73764
R4253 XFE_O.HB.n25 XFE_O.HB.t14 5.73764
R4254 XFE_O.HB.n26 XFE_O.HB.t15 5.71396
R4255 XFE_O.HB.n21 XFE_O.HB.t1 5.6429
R4256 XFE_O.HB.n12 XFE_O.HB.n11 5.38537
R4257 XFE_O.HB.n14 XFE_O.HB.n13 5.38537
R4258 XFE_O.HB.n16 XFE_O.HB.n15 5.38537
R4259 XFE_O.HB.n20 XFE_O.HB.n19 5.32067
R4260 XFE_O.HB.n25 XFE_O.HB.n24 5.32067
R4261 XFE_O.HB.n6 XFE_O.HB.n5 4.42851
R4262 XFE_O.HB.n1 XFE_O.HB.n0 4.42851
R4263 XFE_O.HB.n31 XFE_O.HB.n30 4.42851
R4264 XFE_O.HB.n18 XFE_O.HB.n10 3.48311
R4265 XFE_O.HB.n27 XFE_O.HB.n23 2.34833
R4266 XFE_O.HB.n35 XFE_O.HB.n28 1.17441
R4267 XFE_O.HB.n22 XFE_O.HB.n18 1.17441
R4268 XFE_O.HB.n23 XFE_O.HB.n22 0.587457
R4269 XFE_O.HB.n19 XFE_O.HB.t0 0.228
R4270 XFE_O.HB.n19 XFE_O.HB.t4 0.228
R4271 XFE_O.HB.n24 XFE_O.HB.t13 0.228
R4272 XFE_O.HB.n24 XFE_O.HB.t16 0.228
R4273 XFE_O.HB.n11 XFE_O.HB.t10 0.20525
R4274 XFE_O.HB.n11 XFE_O.HB.t11 0.20525
R4275 XFE_O.HB.n13 XFE_O.HB.t8 0.20525
R4276 XFE_O.HB.n13 XFE_O.HB.t9 0.20525
R4277 XFE_O.HB.n15 XFE_O.HB.t6 0.20525
R4278 XFE_O.HB.n15 XFE_O.HB.t7 0.20525
R4279 XFE_O.HB.n14 XFE_O.HB.n12 0.189974
R4280 XFE_O.HB.n34 XFE_O.HB.n29 0.1205
R4281 XFE_O.HB.n17 XFE_O.HB.n16 0.0952368
R4282 XFE_O.HB.n17 XFE_O.HB.n14 0.0952368
R4283 XFE_O.HB.n21 XFE_O.HB.n20 0.0952368
R4284 XFE_O.HB.n9 XFE_O.HB.n4 0.0785
R4285 XFE_O.HB XFE_O.HB.n35 0.0396304
R4286 XFE_O.HB.n26 XFE_O.HB.n25 0.0241842
R4287 XFE_O.H.n6 XFE_O.H.t17 142.148
R4288 XFE_O.H.n1 XFE_O.H.t25 113.632
R4289 XFE_O.H.n30 XFE_O.H.t18 113.632
R4290 XFE_O.H.n24 XFE_O.H.t28 113.632
R4291 XFE_O.H.n2 XFE_O.H.t24 109.174
R4292 XFE_O.H.n3 XFE_O.H.t23 109.174
R4293 XFE_O.H.n0 XFE_O.H.t22 109.174
R4294 XFE_O.H.n32 XFE_O.H.t20 109.174
R4295 XFE_O.H.n33 XFE_O.H.t21 109.174
R4296 XFE_O.H.n31 XFE_O.H.t19 109.174
R4297 XFE_O.H.n25 XFE_O.H.t27 109.174
R4298 XFE_O.H.n26 XFE_O.H.t26 109.174
R4299 XFE_O.H.n5 XFE_O.H.n0 18.5179
R4300 XFE_O.H.n34 XFE_O.H.n33 18.5179
R4301 XFE_O.H.n4 XFE_O.H.n3 18.4942
R4302 XFE_O.H.n32 XFE_O.H.n29 18.4942
R4303 XFE_O.H.n27 XFE_O.H.n26 18.4942
R4304 XFE_O.H.n10 XFE_O.H.n9 17.7266
R4305 XFE_O.H.n6 XFE_O.H.n5 16.7679
R4306 XFE_O.H.n28 XFE_O.H.n27 16.1533
R4307 XFE_O.H.n11 XFE_O.H.t12 15.3418
R4308 XFE_O.H.n35 XFE_O.H.n34 14.3418
R4309 XFE_O.H.n10 XFE_O.H.n6 13.657
R4310 XFE_O.H.n15 XFE_O.H.n14 13.0309
R4311 XFE_O.H.n3 XFE_O.H.n2 11.6805
R4312 XFE_O.H.n3 XFE_O.H.n0 11.6805
R4313 XFE_O.H.n32 XFE_O.H.n31 11.6805
R4314 XFE_O.H.n33 XFE_O.H.n32 11.6805
R4315 XFE_O.H.n26 XFE_O.H.n25 11.6805
R4316 XFE_O.H.n23 XFE_O.H.n22 9.70485
R4317 XFE_O.H.n4 XFE_O.H.n1 7.17687
R4318 XFE_O.H.n30 XFE_O.H.n29 7.17687
R4319 XFE_O.H.n27 XFE_O.H.n24 7.17687
R4320 XFE_O.H.n17 XFE_O.H.t8 5.7796
R4321 XFE_O.H.n21 XFE_O.H.t1 5.7796
R4322 XFE_O.H.n13 XFE_O.H.t16 5.73764
R4323 XFE_O.H.n8 XFE_O.H.t9 5.73764
R4324 XFE_O.H.n14 XFE_O.H.t13 5.6429
R4325 XFE_O.H.n9 XFE_O.H.t0 5.6429
R4326 XFE_O.H.n17 XFE_O.H.n16 5.38537
R4327 XFE_O.H.n19 XFE_O.H.n18 5.38537
R4328 XFE_O.H.n21 XFE_O.H.n20 5.38537
R4329 XFE_O.H.n13 XFE_O.H.n12 5.32067
R4330 XFE_O.H.n8 XFE_O.H.n7 5.32067
R4331 XFE_O.H.n2 XFE_O.H.n1 4.42851
R4332 XFE_O.H.n31 XFE_O.H.n30 4.42851
R4333 XFE_O.H.n25 XFE_O.H.n24 4.42851
R4334 XFE_O.H.n28 XFE_O.H.n23 2.97441
R4335 XFE_O.H.n11 XFE_O.H.n10 2.73963
R4336 XFE_O.H.n23 XFE_O.H.n15 1.17441
R4337 XFE_O.H.n35 XFE_O.H.n28 0.587457
R4338 XFE_O.H.n15 XFE_O.H.n11 0.391804
R4339 XFE_O.H.n12 XFE_O.H.t14 0.228
R4340 XFE_O.H.n12 XFE_O.H.t15 0.228
R4341 XFE_O.H.n7 XFE_O.H.t11 0.228
R4342 XFE_O.H.n7 XFE_O.H.t10 0.228
R4343 XFE_O.H.n16 XFE_O.H.t6 0.20525
R4344 XFE_O.H.n16 XFE_O.H.t7 0.20525
R4345 XFE_O.H.n18 XFE_O.H.t4 0.20525
R4346 XFE_O.H.n18 XFE_O.H.t5 0.20525
R4347 XFE_O.H.n20 XFE_O.H.t2 0.20525
R4348 XFE_O.H.n20 XFE_O.H.t3 0.20525
R4349 XFE_O.H.n19 XFE_O.H.n17 0.189974
R4350 XFE_O.H.n22 XFE_O.H.n21 0.0952368
R4351 XFE_O.H.n22 XFE_O.H.n19 0.0952368
R4352 XFE_O.H.n14 XFE_O.H.n13 0.0952368
R4353 XFE_O.H.n9 XFE_O.H.n8 0.0952368
R4354 XFE_O.H.n5 XFE_O.H.n4 0.0785
R4355 XFE_O.H.n34 XFE_O.H.n29 0.0785
R4356 XFE_O.H XFE_O.H.n35 0.0396304
R4357 XFE_E.H.n12 XFE_E.H.t21 142.148
R4358 XFE_E.H.n1 XFE_E.H.t20 113.632
R4359 XFE_E.H.n30 XFE_E.H.t22 113.632
R4360 XFE_E.H.n7 XFE_E.H.t25 113.632
R4361 XFE_E.H.n2 XFE_E.H.t19 109.174
R4362 XFE_E.H.n3 XFE_E.H.t18 109.174
R4363 XFE_E.H.n0 XFE_E.H.t17 109.174
R4364 XFE_E.H.n32 XFE_E.H.t24 109.174
R4365 XFE_E.H.n31 XFE_E.H.t23 109.174
R4366 XFE_E.H.n9 XFE_E.H.t27 109.174
R4367 XFE_E.H.n10 XFE_E.H.t28 109.174
R4368 XFE_E.H.n8 XFE_E.H.t26 109.174
R4369 XFE_E.H.n5 XFE_E.H.n0 18.5179
R4370 XFE_E.H.n11 XFE_E.H.n10 18.5179
R4371 XFE_E.H.n4 XFE_E.H.n3 18.4942
R4372 XFE_E.H.n33 XFE_E.H.n32 18.4942
R4373 XFE_E.H.n9 XFE_E.H.n6 18.4942
R4374 XFE_E.H.n16 XFE_E.H.n15 17.7266
R4375 XFE_E.H.n12 XFE_E.H.n11 16.7679
R4376 XFE_E.H.n34 XFE_E.H.n33 16.1533
R4377 XFE_E.H.n17 XFE_E.H.t3 15.3418
R4378 XFE_E.H XFE_E.H.n5 14.3809
R4379 XFE_E.H.n16 XFE_E.H.n12 13.657
R4380 XFE_E.H.n21 XFE_E.H.n20 13.0309
R4381 XFE_E.H.n3 XFE_E.H.n2 11.6805
R4382 XFE_E.H.n3 XFE_E.H.n0 11.6805
R4383 XFE_E.H.n32 XFE_E.H.n31 11.6805
R4384 XFE_E.H.n9 XFE_E.H.n8 11.6805
R4385 XFE_E.H.n10 XFE_E.H.n9 11.6805
R4386 XFE_E.H.n29 XFE_E.H.n28 9.70485
R4387 XFE_E.H.n4 XFE_E.H.n1 7.17687
R4388 XFE_E.H.n33 XFE_E.H.n30 7.17687
R4389 XFE_E.H.n7 XFE_E.H.n6 7.17687
R4390 XFE_E.H.n23 XFE_E.H.t16 5.7796
R4391 XFE_E.H.n25 XFE_E.H.t9 5.7796
R4392 XFE_E.H.n19 XFE_E.H.t2 5.73764
R4393 XFE_E.H.n14 XFE_E.H.t5 5.73764
R4394 XFE_E.H.n20 XFE_E.H.t4 5.6429
R4395 XFE_E.H.n15 XFE_E.H.t6 5.6429
R4396 XFE_E.H.n23 XFE_E.H.n22 5.38537
R4397 XFE_E.H.n27 XFE_E.H.n26 5.38537
R4398 XFE_E.H.n25 XFE_E.H.n24 5.38537
R4399 XFE_E.H.n19 XFE_E.H.n18 5.32067
R4400 XFE_E.H.n14 XFE_E.H.n13 5.32067
R4401 XFE_E.H.n2 XFE_E.H.n1 4.42851
R4402 XFE_E.H.n31 XFE_E.H.n30 4.42851
R4403 XFE_E.H.n8 XFE_E.H.n7 4.42851
R4404 XFE_E.H.n34 XFE_E.H.n29 2.97441
R4405 XFE_E.H.n17 XFE_E.H.n16 2.73963
R4406 XFE_E.H.n29 XFE_E.H.n21 1.17441
R4407 XFE_E.H XFE_E.H.n34 0.548326
R4408 XFE_E.H.n21 XFE_E.H.n17 0.391804
R4409 XFE_E.H.n18 XFE_E.H.t1 0.228
R4410 XFE_E.H.n18 XFE_E.H.t0 0.228
R4411 XFE_E.H.n13 XFE_E.H.t8 0.228
R4412 XFE_E.H.n13 XFE_E.H.t7 0.228
R4413 XFE_E.H.n22 XFE_E.H.t14 0.20525
R4414 XFE_E.H.n22 XFE_E.H.t15 0.20525
R4415 XFE_E.H.n26 XFE_E.H.t12 0.20525
R4416 XFE_E.H.n26 XFE_E.H.t13 0.20525
R4417 XFE_E.H.n24 XFE_E.H.t10 0.20525
R4418 XFE_E.H.n24 XFE_E.H.t11 0.20525
R4419 XFE_E.H.n27 XFE_E.H.n25 0.189974
R4420 XFE_E.H.n28 XFE_E.H.n27 0.0952368
R4421 XFE_E.H.n28 XFE_E.H.n23 0.0952368
R4422 XFE_E.H.n20 XFE_E.H.n19 0.0952368
R4423 XFE_E.H.n15 XFE_E.H.n14 0.0952368
R4424 XFE_E.H.n5 XFE_E.H.n4 0.0785
R4425 XFE_E.H.n11 XFE_E.H.n6 0.0785
R4426 XFE_E.HB.n34 XFE_E.HB.t17 142.571
R4427 XFE_E.HB.n1 XFE_E.HB.t25 113.632
R4428 XFE_E.HB.n11 XFE_E.HB.t21 113.632
R4429 XFE_E.HB.n6 XFE_E.HB.t26 113.632
R4430 XFE_E.HB.n2 XFE_E.HB.t24 109.174
R4431 XFE_E.HB.n3 XFE_E.HB.t23 109.174
R4432 XFE_E.HB.n4 XFE_E.HB.t22 109.174
R4433 XFE_E.HB.n12 XFE_E.HB.t20 109.174
R4434 XFE_E.HB.n13 XFE_E.HB.t19 109.174
R4435 XFE_E.HB.n10 XFE_E.HB.t18 109.174
R4436 XFE_E.HB.n8 XFE_E.HB.t28 109.174
R4437 XFE_E.HB.n7 XFE_E.HB.t27 109.174
R4438 XFE_E.HB.n15 XFE_E.HB.n10 18.5179
R4439 XFE_E.HB.n3 XFE_E.HB.n0 18.4942
R4440 XFE_E.HB.n5 XFE_E.HB.n4 18.4942
R4441 XFE_E.HB.n14 XFE_E.HB.n13 18.4942
R4442 XFE_E.HB.n9 XFE_E.HB.n8 18.4942
R4443 XFE_E.HB.n33 XFE_E.HB.n32 17.4527
R4444 XFE_E.HB.n16 XFE_E.HB.n9 16.4663
R4445 XFE_E.HB XFE_E.HB.n5 15.8585
R4446 XFE_E.HB.n29 XFE_E.HB.t12 15.1863
R4447 XFE_E.HB.n16 XFE_E.HB.n15 14.6157
R4448 XFE_E.HB.n34 XFE_E.HB.n33 13.344
R4449 XFE_E.HB.n28 XFE_E.HB.n27 12.757
R4450 XFE_E.HB.n3 XFE_E.HB.n2 11.6805
R4451 XFE_E.HB.n4 XFE_E.HB.n3 11.6805
R4452 XFE_E.HB.n13 XFE_E.HB.n12 11.6805
R4453 XFE_E.HB.n13 XFE_E.HB.n10 11.6805
R4454 XFE_E.HB.n8 XFE_E.HB.n7 11.6805
R4455 XFE_E.HB.n24 XFE_E.HB.n23 9.43093
R4456 XFE_E.HB.n1 XFE_E.HB.n0 7.17687
R4457 XFE_E.HB.n14 XFE_E.HB.n11 7.17687
R4458 XFE_E.HB.n9 XFE_E.HB.n6 7.17687
R4459 XFE_E.HB.n18 XFE_E.HB.t10 5.7796
R4460 XFE_E.HB.n20 XFE_E.HB.t3 5.7796
R4461 XFE_E.HB.n26 XFE_E.HB.t13 5.73764
R4462 XFE_E.HB.n31 XFE_E.HB.t11 5.73764
R4463 XFE_E.HB.n32 XFE_E.HB.t2 5.71396
R4464 XFE_E.HB.n27 XFE_E.HB.t16 5.6429
R4465 XFE_E.HB.n18 XFE_E.HB.n17 5.38537
R4466 XFE_E.HB.n22 XFE_E.HB.n21 5.38537
R4467 XFE_E.HB.n20 XFE_E.HB.n19 5.38537
R4468 XFE_E.HB.n26 XFE_E.HB.n25 5.32067
R4469 XFE_E.HB.n31 XFE_E.HB.n30 5.32067
R4470 XFE_E.HB.n2 XFE_E.HB.n1 4.42851
R4471 XFE_E.HB.n12 XFE_E.HB.n11 4.42851
R4472 XFE_E.HB.n7 XFE_E.HB.n6 4.42851
R4473 XFE_E.HB.n24 XFE_E.HB.n16 3.48311
R4474 XFE_E.HB.n33 XFE_E.HB.n29 2.34833
R4475 XFE_E.HB.n28 XFE_E.HB.n24 1.17441
R4476 XFE_E.HB XFE_E.HB.n34 1.13528
R4477 XFE_E.HB.n29 XFE_E.HB.n28 0.587457
R4478 XFE_E.HB.n25 XFE_E.HB.t14 0.228
R4479 XFE_E.HB.n25 XFE_E.HB.t15 0.228
R4480 XFE_E.HB.n30 XFE_E.HB.t1 0.228
R4481 XFE_E.HB.n30 XFE_E.HB.t0 0.228
R4482 XFE_E.HB.n17 XFE_E.HB.t8 0.20525
R4483 XFE_E.HB.n17 XFE_E.HB.t9 0.20525
R4484 XFE_E.HB.n21 XFE_E.HB.t6 0.20525
R4485 XFE_E.HB.n21 XFE_E.HB.t7 0.20525
R4486 XFE_E.HB.n19 XFE_E.HB.t4 0.20525
R4487 XFE_E.HB.n19 XFE_E.HB.t5 0.20525
R4488 XFE_E.HB.n22 XFE_E.HB.n20 0.189974
R4489 XFE_E.HB.n5 XFE_E.HB.n0 0.1205
R4490 XFE_E.HB.n23 XFE_E.HB.n22 0.0952368
R4491 XFE_E.HB.n23 XFE_E.HB.n18 0.0952368
R4492 XFE_E.HB.n27 XFE_E.HB.n26 0.0952368
R4493 XFE_E.HB.n15 XFE_E.HB.n14 0.0785
R4494 XFE_E.HB.n32 XFE_E.HB.n31 0.0241842
R4495 XFE_O.XP.t43 XFE_O.XP.n25 127.788
R4496 XFE_O.XP.t32 XFE_O.XP.n10 127.788
R4497 XFE_O.XP.t34 XFE_O.XP.n7 127.668
R4498 XFE_O.XP.n25 XFE_O.XP.t42 127.668
R4499 XFE_O.XP.n24 XFE_O.XP.t41 127.668
R4500 XFE_O.XP.n23 XFE_O.XP.t40 127.668
R4501 XFE_O.XP.n22 XFE_O.XP.t39 127.668
R4502 XFE_O.XP.n21 XFE_O.XP.t38 127.668
R4503 XFE_O.XP.n20 XFE_O.XP.t37 127.668
R4504 XFE_O.XP.t36 XFE_O.XP.n8 127.668
R4505 XFE_O.XP.n35 XFE_O.XP.t35 127.668
R4506 XFE_O.XP.n10 XFE_O.XP.t33 127.668
R4507 XFE_O.XP.n26 XFE_O.XP.t43 113.632
R4508 XFE_O.XP.n11 XFE_O.XP.t32 113.632
R4509 XFE_O.XP.n1 XFE_O.XP.t53 113.632
R4510 XFE_O.XP.n38 XFE_O.XP.t54 113.632
R4511 XFE_O.XP.n62 XFE_O.XP.t45 113.632
R4512 XFE_O.XP.n65 XFE_O.XP.t49 113.632
R4513 XFE_O.XP.n38 XFE_O.XP.t55 113.603
R4514 XFE_O.XP.n62 XFE_O.XP.t44 113.603
R4515 XFE_O.XP.n13 XFE_O.XP.t34 109.174
R4516 XFE_O.XP.t42 XFE_O.XP.n19 109.174
R4517 XFE_O.XP.n28 XFE_O.XP.t41 109.174
R4518 XFE_O.XP.n29 XFE_O.XP.t40 109.174
R4519 XFE_O.XP.n30 XFE_O.XP.t39 109.174
R4520 XFE_O.XP.n31 XFE_O.XP.t38 109.174
R4521 XFE_O.XP.n32 XFE_O.XP.t37 109.174
R4522 XFE_O.XP.n33 XFE_O.XP.t36 109.174
R4523 XFE_O.XP.t35 XFE_O.XP.n34 109.174
R4524 XFE_O.XP.t33 XFE_O.XP.n9 109.174
R4525 XFE_O.XP.n2 XFE_O.XP.t52 109.174
R4526 XFE_O.XP.n3 XFE_O.XP.t51 109.174
R4527 XFE_O.XP.n4 XFE_O.XP.t50 109.174
R4528 XFE_O.XP.n66 XFE_O.XP.t48 109.174
R4529 XFE_O.XP.n67 XFE_O.XP.t47 109.174
R4530 XFE_O.XP.n64 XFE_O.XP.t46 109.174
R4531 XFE_O.XP.n39 XFE_O.XP.n38 26.8696
R4532 XFE_O.XP.n63 XFE_O.XP.n62 22.8718
R4533 XFE_O.XP.n37 XFE_O.XP.n5 20.2802
R4534 XFE_O.XP.n69 XFE_O.XP.n64 18.5179
R4535 XFE_O.XP.n13 XFE_O.XP.n12 18.4942
R4536 XFE_O.XP.n28 XFE_O.XP.n27 18.4942
R4537 XFE_O.XP.n29 XFE_O.XP.n18 18.4942
R4538 XFE_O.XP.n30 XFE_O.XP.n17 18.4942
R4539 XFE_O.XP.n31 XFE_O.XP.n16 18.4942
R4540 XFE_O.XP.n32 XFE_O.XP.n15 18.4942
R4541 XFE_O.XP.n33 XFE_O.XP.n14 18.4942
R4542 XFE_O.XP.n34 XFE_O.XP.n6 18.4942
R4543 XFE_O.XP.n3 XFE_O.XP.n0 18.4942
R4544 XFE_O.XP.n5 XFE_O.XP.n4 18.4942
R4545 XFE_O.XP.n68 XFE_O.XP.n67 18.4942
R4546 XFE_O.XP.n49 XFE_O.XP.n48 16.6309
R4547 XFE_O.XP.n70 XFE_O.XP.n69 14.8896
R4548 XFE_O.XP.n80 XFE_O.XP.n79 14.2831
R4549 XFE_O.XP.n47 XFE_O.XP.n46 14.2831
R4550 XFE_O.XP.n61 XFE_O.XP.n60 11.7396
R4551 XFE_O.XP.n29 XFE_O.XP.n28 11.6805
R4552 XFE_O.XP.n28 XFE_O.XP.n19 11.6805
R4553 XFE_O.XP.n30 XFE_O.XP.n29 11.6805
R4554 XFE_O.XP.n31 XFE_O.XP.n30 11.6805
R4555 XFE_O.XP.n32 XFE_O.XP.n31 11.6805
R4556 XFE_O.XP.n33 XFE_O.XP.n32 11.6805
R4557 XFE_O.XP.n34 XFE_O.XP.n33 11.6805
R4558 XFE_O.XP.n34 XFE_O.XP.n13 11.6805
R4559 XFE_O.XP.n13 XFE_O.XP.n9 11.6805
R4560 XFE_O.XP.n3 XFE_O.XP.n2 11.6805
R4561 XFE_O.XP.n4 XFE_O.XP.n3 11.6805
R4562 XFE_O.XP.n67 XFE_O.XP.n66 11.6805
R4563 XFE_O.XP.n67 XFE_O.XP.n64 11.6805
R4564 XFE_O.XP.n36 XFE_O.XP.n6 10.8396
R4565 XFE_O.XP.n36 XFE_O.XP.n35 9.0005
R4566 XFE_O.XP.n27 XFE_O.XP.n26 7.17687
R4567 XFE_O.XP.n12 XFE_O.XP.n11 7.17687
R4568 XFE_O.XP.n1 XFE_O.XP.n0 7.17687
R4569 XFE_O.XP.n68 XFE_O.XP.n65 7.17687
R4570 XFE_O.XP.n37 XFE_O.XP.n36 6.94615
R4571 XFE_O.XP.n51 XFE_O.XP.t7 5.7796
R4572 XFE_O.XP.n57 XFE_O.XP.t8 5.7796
R4573 XFE_O.XP.n72 XFE_O.XP.t31 5.73764
R4574 XFE_O.XP.n41 XFE_O.XP.t18 5.73764
R4575 XFE_O.XP.n45 XFE_O.XP.t17 5.73764
R4576 XFE_O.XP.n48 XFE_O.XP.t13 5.66659
R4577 XFE_O.XP.n48 XFE_O.XP.t2 5.61922
R4578 XFE_O.XP.n79 XFE_O.XP.t22 5.57185
R4579 XFE_O.XP.n51 XFE_O.XP.n50 5.38537
R4580 XFE_O.XP.n53 XFE_O.XP.n52 5.38537
R4581 XFE_O.XP.n55 XFE_O.XP.n54 5.38537
R4582 XFE_O.XP.n59 XFE_O.XP.n58 5.38537
R4583 XFE_O.XP.n57 XFE_O.XP.n56 5.38537
R4584 XFE_O.XP.n41 XFE_O.XP.n40 5.32067
R4585 XFE_O.XP.n43 XFE_O.XP.n42 5.32067
R4586 XFE_O.XP.n45 XFE_O.XP.n44 5.32067
R4587 XFE_O.XP.n72 XFE_O.XP.n71 5.32067
R4588 XFE_O.XP.n74 XFE_O.XP.n73 5.32067
R4589 XFE_O.XP.n76 XFE_O.XP.n75 5.32067
R4590 XFE_O.XP.n78 XFE_O.XP.n77 5.32067
R4591 XFE_O.XP.n26 XFE_O.XP.n19 4.42851
R4592 XFE_O.XP.n11 XFE_O.XP.n9 4.42851
R4593 XFE_O.XP.n2 XFE_O.XP.n1 4.42851
R4594 XFE_O.XP.n66 XFE_O.XP.n65 4.42851
R4595 XFE_O.XP.n39 XFE_O.XP.n37 3.71789
R4596 XFE_O.XP.n61 XFE_O.XP.n49 3.13093
R4597 XFE_O.XP.n49 XFE_O.XP.n47 1.76137
R4598 XFE_O.XP.n47 XFE_O.XP.n39 1.72224
R4599 XFE_O.XP.n80 XFE_O.XP.n70 1.33093
R4600 XFE_O.XP.n63 XFE_O.XP.n61 1.01789
R4601 XFE_O.XP.n70 XFE_O.XP.n63 0.391804
R4602 XFE_O.XP.n40 XFE_O.XP.t20 0.228
R4603 XFE_O.XP.n40 XFE_O.XP.t21 0.228
R4604 XFE_O.XP.n42 XFE_O.XP.t14 0.228
R4605 XFE_O.XP.n42 XFE_O.XP.t16 0.228
R4606 XFE_O.XP.n44 XFE_O.XP.t15 0.228
R4607 XFE_O.XP.n44 XFE_O.XP.t19 0.228
R4608 XFE_O.XP.n71 XFE_O.XP.t29 0.228
R4609 XFE_O.XP.n71 XFE_O.XP.t30 0.228
R4610 XFE_O.XP.n73 XFE_O.XP.t27 0.228
R4611 XFE_O.XP.n73 XFE_O.XP.t28 0.228
R4612 XFE_O.XP.n75 XFE_O.XP.t25 0.228
R4613 XFE_O.XP.n75 XFE_O.XP.t26 0.228
R4614 XFE_O.XP.n77 XFE_O.XP.t23 0.228
R4615 XFE_O.XP.n77 XFE_O.XP.t24 0.228
R4616 XFE_O.XP.n50 XFE_O.XP.t10 0.20525
R4617 XFE_O.XP.n50 XFE_O.XP.t9 0.20525
R4618 XFE_O.XP.n52 XFE_O.XP.t1 0.20525
R4619 XFE_O.XP.n52 XFE_O.XP.t0 0.20525
R4620 XFE_O.XP.n54 XFE_O.XP.t12 0.20525
R4621 XFE_O.XP.n54 XFE_O.XP.t11 0.20525
R4622 XFE_O.XP.n58 XFE_O.XP.t4 0.20525
R4623 XFE_O.XP.n58 XFE_O.XP.t3 0.20525
R4624 XFE_O.XP.n56 XFE_O.XP.t6 0.20525
R4625 XFE_O.XP.n56 XFE_O.XP.t5 0.20525
R4626 XFE_O.XP.n78 XFE_O.XP.n76 0.189974
R4627 XFE_O.XP.n76 XFE_O.XP.n74 0.189974
R4628 XFE_O.XP.n74 XFE_O.XP.n72 0.189974
R4629 XFE_O.XP.n43 XFE_O.XP.n41 0.189974
R4630 XFE_O.XP.n59 XFE_O.XP.n57 0.189974
R4631 XFE_O.XP.n55 XFE_O.XP.n53 0.189974
R4632 XFE_O.XP.n53 XFE_O.XP.n51 0.189974
R4633 XFE_O.XP.n79 XFE_O.XP.n78 0.166289
R4634 XFE_O.XP.n10 XFE_O.XP.n7 0.1205
R4635 XFE_O.XP.n25 XFE_O.XP.n24 0.1205
R4636 XFE_O.XP.n24 XFE_O.XP.n23 0.1205
R4637 XFE_O.XP.n23 XFE_O.XP.n22 0.1205
R4638 XFE_O.XP.n22 XFE_O.XP.n21 0.1205
R4639 XFE_O.XP.n21 XFE_O.XP.n20 0.1205
R4640 XFE_O.XP.n20 XFE_O.XP.n8 0.1205
R4641 XFE_O.XP.n27 XFE_O.XP.n18 0.1205
R4642 XFE_O.XP.n18 XFE_O.XP.n17 0.1205
R4643 XFE_O.XP.n17 XFE_O.XP.n16 0.1205
R4644 XFE_O.XP.n16 XFE_O.XP.n15 0.1205
R4645 XFE_O.XP.n15 XFE_O.XP.n14 0.1205
R4646 XFE_O.XP.n5 XFE_O.XP.n0 0.1205
R4647 XFE_O.XP.n12 XFE_O.XP.n6 0.1085
R4648 XFE_O.XP.n35 XFE_O.XP.n7 0.1085
R4649 XFE_O.XP.n35 XFE_O.XP.n8 0.1085
R4650 XFE_O.XP.n14 XFE_O.XP.n6 0.1085
R4651 XFE_O.XP.n46 XFE_O.XP.n45 0.0952368
R4652 XFE_O.XP.n46 XFE_O.XP.n43 0.0952368
R4653 XFE_O.XP.n60 XFE_O.XP.n59 0.0952368
R4654 XFE_O.XP.n60 XFE_O.XP.n55 0.0952368
R4655 XFE_O.XP.n69 XFE_O.XP.n68 0.0785
R4656 XFE_O.XP XFE_O.XP.n80 0.0396304
R4657 XFE_O.XN.t43 XFE_O.XN.n60 127.788
R4658 XFE_O.XN.t32 XFE_O.XN.n45 127.788
R4659 XFE_O.XN.t34 XFE_O.XN.n42 127.668
R4660 XFE_O.XN.n60 XFE_O.XN.t42 127.668
R4661 XFE_O.XN.n59 XFE_O.XN.t41 127.668
R4662 XFE_O.XN.n58 XFE_O.XN.t40 127.668
R4663 XFE_O.XN.n57 XFE_O.XN.t39 127.668
R4664 XFE_O.XN.n56 XFE_O.XN.t38 127.668
R4665 XFE_O.XN.n55 XFE_O.XN.t37 127.668
R4666 XFE_O.XN.t36 XFE_O.XN.n43 127.668
R4667 XFE_O.XN.n70 XFE_O.XN.t35 127.668
R4668 XFE_O.XN.n45 XFE_O.XN.t33 127.668
R4669 XFE_O.XN.n16 XFE_O.XN.t44 113.632
R4670 XFE_O.XN.n10 XFE_O.XN.t46 113.632
R4671 XFE_O.XN.n61 XFE_O.XN.t43 113.632
R4672 XFE_O.XN.n46 XFE_O.XN.t32 113.632
R4673 XFE_O.XN.n39 XFE_O.XN.t51 113.632
R4674 XFE_O.XN.n74 XFE_O.XN.t55 113.632
R4675 XFE_O.XN.n16 XFE_O.XN.t45 113.603
R4676 XFE_O.XN.n39 XFE_O.XN.t50 113.603
R4677 XFE_O.XN.n12 XFE_O.XN.t48 109.174
R4678 XFE_O.XN.n13 XFE_O.XN.t49 109.174
R4679 XFE_O.XN.n11 XFE_O.XN.t47 109.174
R4680 XFE_O.XN.n48 XFE_O.XN.t34 109.174
R4681 XFE_O.XN.t42 XFE_O.XN.n54 109.174
R4682 XFE_O.XN.n63 XFE_O.XN.t41 109.174
R4683 XFE_O.XN.n64 XFE_O.XN.t40 109.174
R4684 XFE_O.XN.n65 XFE_O.XN.t39 109.174
R4685 XFE_O.XN.n66 XFE_O.XN.t38 109.174
R4686 XFE_O.XN.n67 XFE_O.XN.t37 109.174
R4687 XFE_O.XN.n68 XFE_O.XN.t36 109.174
R4688 XFE_O.XN.t35 XFE_O.XN.n69 109.174
R4689 XFE_O.XN.t33 XFE_O.XN.n44 109.174
R4690 XFE_O.XN.n75 XFE_O.XN.t54 109.174
R4691 XFE_O.XN.n76 XFE_O.XN.t53 109.174
R4692 XFE_O.XN.n73 XFE_O.XN.t52 109.174
R4693 XFE_O.XN.n40 XFE_O.XN.n39 26.5957
R4694 XFE_O.XN.n17 XFE_O.XN.n16 23.1457
R4695 XFE_O.XN.n79 XFE_O.XN.n78 19.3114
R4696 XFE_O.XN.n14 XFE_O.XN.n13 18.5179
R4697 XFE_O.XN.n78 XFE_O.XN.n73 18.5179
R4698 XFE_O.XN.n12 XFE_O.XN.n9 18.4942
R4699 XFE_O.XN.n48 XFE_O.XN.n47 18.4942
R4700 XFE_O.XN.n63 XFE_O.XN.n62 18.4942
R4701 XFE_O.XN.n64 XFE_O.XN.n53 18.4942
R4702 XFE_O.XN.n65 XFE_O.XN.n52 18.4942
R4703 XFE_O.XN.n66 XFE_O.XN.n51 18.4942
R4704 XFE_O.XN.n67 XFE_O.XN.n50 18.4942
R4705 XFE_O.XN.n68 XFE_O.XN.n49 18.4942
R4706 XFE_O.XN.n69 XFE_O.XN.n41 18.4942
R4707 XFE_O.XN.n77 XFE_O.XN.n76 18.4942
R4708 XFE_O.XN.n31 XFE_O.XN.n30 16.357
R4709 XFE_O.XN.n15 XFE_O.XN.n8 15.2222
R4710 XFE_O.XN.n15 XFE_O.XN.n14 14.6157
R4711 XFE_O.XN.n38 XFE_O.XN.n37 12.757
R4712 XFE_O.XN.n29 XFE_O.XN.n28 12.0135
R4713 XFE_O.XN.n12 XFE_O.XN.n11 11.6805
R4714 XFE_O.XN.n13 XFE_O.XN.n12 11.6805
R4715 XFE_O.XN.n64 XFE_O.XN.n63 11.6805
R4716 XFE_O.XN.n63 XFE_O.XN.n54 11.6805
R4717 XFE_O.XN.n65 XFE_O.XN.n64 11.6805
R4718 XFE_O.XN.n66 XFE_O.XN.n65 11.6805
R4719 XFE_O.XN.n67 XFE_O.XN.n66 11.6805
R4720 XFE_O.XN.n68 XFE_O.XN.n67 11.6805
R4721 XFE_O.XN.n69 XFE_O.XN.n68 11.6805
R4722 XFE_O.XN.n69 XFE_O.XN.n48 11.6805
R4723 XFE_O.XN.n48 XFE_O.XN.n44 11.6805
R4724 XFE_O.XN.n76 XFE_O.XN.n75 11.6805
R4725 XFE_O.XN.n76 XFE_O.XN.n73 11.6805
R4726 XFE_O.XN.n71 XFE_O.XN.n41 10.8396
R4727 XFE_O.XN.n71 XFE_O.XN.n70 9.0005
R4728 XFE_O.XN.n72 XFE_O.XN.n71 7.22007
R4729 XFE_O.XN.n10 XFE_O.XN.n9 7.17687
R4730 XFE_O.XN.n62 XFE_O.XN.n61 7.17687
R4731 XFE_O.XN.n47 XFE_O.XN.n46 7.17687
R4732 XFE_O.XN.n77 XFE_O.XN.n74 7.17687
R4733 XFE_O.XN.n19 XFE_O.XN.t29 5.7796
R4734 XFE_O.XN.n25 XFE_O.XN.t18 5.7796
R4735 XFE_O.XN.n1 XFE_O.XN.t0 5.73764
R4736 XFE_O.XN.n30 XFE_O.XN.t31 5.73764
R4737 XFE_O.XN.n8 XFE_O.XN.t9 5.6429
R4738 XFE_O.XN.n30 XFE_O.XN.t30 5.54817
R4739 XFE_O.XN.n37 XFE_O.XN.n32 5.51014
R4740 XFE_O.XN.n36 XFE_O.XN.n34 5.51014
R4741 XFE_O.XN.n19 XFE_O.XN.n18 5.38537
R4742 XFE_O.XN.n21 XFE_O.XN.n20 5.38537
R4743 XFE_O.XN.n23 XFE_O.XN.n22 5.38537
R4744 XFE_O.XN.n27 XFE_O.XN.n26 5.38537
R4745 XFE_O.XN.n25 XFE_O.XN.n24 5.38537
R4746 XFE_O.XN.n7 XFE_O.XN.n6 5.32067
R4747 XFE_O.XN.n5 XFE_O.XN.n4 5.32067
R4748 XFE_O.XN.n3 XFE_O.XN.n2 5.32067
R4749 XFE_O.XN.n1 XFE_O.XN.n0 5.32067
R4750 XFE_O.XN.n37 XFE_O.XN.n33 5.32067
R4751 XFE_O.XN.n36 XFE_O.XN.n35 5.32067
R4752 XFE_O.XN.n11 XFE_O.XN.n10 4.42851
R4753 XFE_O.XN.n61 XFE_O.XN.n54 4.42851
R4754 XFE_O.XN.n46 XFE_O.XN.n44 4.42851
R4755 XFE_O.XN.n75 XFE_O.XN.n74 4.42851
R4756 XFE_O.XN.n72 XFE_O.XN.n40 2.93528
R4757 XFE_O.XN.n31 XFE_O.XN.n29 2.93528
R4758 XFE_O.XN.n40 XFE_O.XN.n38 1.72224
R4759 XFE_O.XN.n38 XFE_O.XN.n31 1.64398
R4760 XFE_O.XN.n29 XFE_O.XN.n17 1.33093
R4761 XFE_O.XN.n79 XFE_O.XN.n72 0.783109
R4762 XFE_O.XN.n17 XFE_O.XN.n15 0.391804
R4763 XFE_O.XN.n6 XFE_O.XN.t7 0.228
R4764 XFE_O.XN.n6 XFE_O.XN.t8 0.228
R4765 XFE_O.XN.n4 XFE_O.XN.t5 0.228
R4766 XFE_O.XN.n4 XFE_O.XN.t6 0.228
R4767 XFE_O.XN.n2 XFE_O.XN.t3 0.228
R4768 XFE_O.XN.n2 XFE_O.XN.t4 0.228
R4769 XFE_O.XN.n0 XFE_O.XN.t1 0.228
R4770 XFE_O.XN.n0 XFE_O.XN.t2 0.228
R4771 XFE_O.XN.n32 XFE_O.XN.t16 0.228
R4772 XFE_O.XN.n32 XFE_O.XN.t17 0.228
R4773 XFE_O.XN.n33 XFE_O.XN.t14 0.228
R4774 XFE_O.XN.n33 XFE_O.XN.t15 0.228
R4775 XFE_O.XN.n35 XFE_O.XN.t12 0.228
R4776 XFE_O.XN.n35 XFE_O.XN.t13 0.228
R4777 XFE_O.XN.n34 XFE_O.XN.t10 0.228
R4778 XFE_O.XN.n34 XFE_O.XN.t11 0.228
R4779 XFE_O.XN.n18 XFE_O.XN.t27 0.20525
R4780 XFE_O.XN.n18 XFE_O.XN.t28 0.20525
R4781 XFE_O.XN.n20 XFE_O.XN.t25 0.20525
R4782 XFE_O.XN.n20 XFE_O.XN.t26 0.20525
R4783 XFE_O.XN.n22 XFE_O.XN.t23 0.20525
R4784 XFE_O.XN.n22 XFE_O.XN.t24 0.20525
R4785 XFE_O.XN.n26 XFE_O.XN.t21 0.20525
R4786 XFE_O.XN.n26 XFE_O.XN.t22 0.20525
R4787 XFE_O.XN.n24 XFE_O.XN.t19 0.20525
R4788 XFE_O.XN.n24 XFE_O.XN.t20 0.20525
R4789 XFE_O.XN.n27 XFE_O.XN.n25 0.189974
R4790 XFE_O.XN.n23 XFE_O.XN.n21 0.189974
R4791 XFE_O.XN.n21 XFE_O.XN.n19 0.189974
R4792 XFE_O.XN.n3 XFE_O.XN.n1 0.189974
R4793 XFE_O.XN.n5 XFE_O.XN.n3 0.189974
R4794 XFE_O.XN.n7 XFE_O.XN.n5 0.189974
R4795 XFE_O.XN.n37 XFE_O.XN.n36 0.189974
R4796 XFE_O.XN.n45 XFE_O.XN.n42 0.1205
R4797 XFE_O.XN.n60 XFE_O.XN.n59 0.1205
R4798 XFE_O.XN.n59 XFE_O.XN.n58 0.1205
R4799 XFE_O.XN.n58 XFE_O.XN.n57 0.1205
R4800 XFE_O.XN.n57 XFE_O.XN.n56 0.1205
R4801 XFE_O.XN.n56 XFE_O.XN.n55 0.1205
R4802 XFE_O.XN.n55 XFE_O.XN.n43 0.1205
R4803 XFE_O.XN.n62 XFE_O.XN.n53 0.1205
R4804 XFE_O.XN.n53 XFE_O.XN.n52 0.1205
R4805 XFE_O.XN.n52 XFE_O.XN.n51 0.1205
R4806 XFE_O.XN.n51 XFE_O.XN.n50 0.1205
R4807 XFE_O.XN.n50 XFE_O.XN.n49 0.1205
R4808 XFE_O.XN.n47 XFE_O.XN.n41 0.1085
R4809 XFE_O.XN.n70 XFE_O.XN.n42 0.1085
R4810 XFE_O.XN.n70 XFE_O.XN.n43 0.1085
R4811 XFE_O.XN.n49 XFE_O.XN.n41 0.1085
R4812 XFE_O.XN.n28 XFE_O.XN.n27 0.0952368
R4813 XFE_O.XN.n28 XFE_O.XN.n23 0.0952368
R4814 XFE_O.XN.n8 XFE_O.XN.n7 0.0952368
R4815 XFE_O.XN.n14 XFE_O.XN.n9 0.0785
R4816 XFE_O.XN.n78 XFE_O.XN.n77 0.0785
R4817 XFE_O.XN XFE_O.XN.n79 0.0396304
R4818 XFE_E.XN.t43 XFE_E.XN.n71 127.788
R4819 XFE_E.XN.t32 XFE_E.XN.n59 127.788
R4820 XFE_E.XN.t39 XFE_E.XN.n48 127.668
R4821 XFE_E.XN.n71 XFE_E.XN.t42 127.668
R4822 XFE_E.XN.t41 XFE_E.XN.n49 127.668
R4823 XFE_E.XN.n76 XFE_E.XN.t40 127.668
R4824 XFE_E.XN.n59 XFE_E.XN.t33 127.668
R4825 XFE_E.XN.n58 XFE_E.XN.t34 127.668
R4826 XFE_E.XN.n57 XFE_E.XN.t35 127.668
R4827 XFE_E.XN.n56 XFE_E.XN.t36 127.668
R4828 XFE_E.XN.n55 XFE_E.XN.t37 127.668
R4829 XFE_E.XN.n54 XFE_E.XN.t38 127.668
R4830 XFE_E.XN.n72 XFE_E.XN.t43 113.632
R4831 XFE_E.XN.n60 XFE_E.XN.t32 113.632
R4832 XFE_E.XN.n1 XFE_E.XN.t50 113.632
R4833 XFE_E.XN.n45 XFE_E.XN.t54 113.632
R4834 XFE_E.XN.n22 XFE_E.XN.t45 113.632
R4835 XFE_E.XN.n16 XFE_E.XN.t49 113.632
R4836 XFE_E.XN.n45 XFE_E.XN.t55 113.603
R4837 XFE_E.XN.n22 XFE_E.XN.t44 113.603
R4838 XFE_E.XN.n69 XFE_E.XN.t39 109.174
R4839 XFE_E.XN.t42 XFE_E.XN.n70 109.174
R4840 XFE_E.XN.n74 XFE_E.XN.t41 109.174
R4841 XFE_E.XN.t40 XFE_E.XN.n75 109.174
R4842 XFE_E.XN.n61 XFE_E.XN.t33 109.174
R4843 XFE_E.XN.n62 XFE_E.XN.t34 109.174
R4844 XFE_E.XN.n63 XFE_E.XN.t35 109.174
R4845 XFE_E.XN.n64 XFE_E.XN.t36 109.174
R4846 XFE_E.XN.n65 XFE_E.XN.t37 109.174
R4847 XFE_E.XN.t38 XFE_E.XN.n50 109.174
R4848 XFE_E.XN.n3 XFE_E.XN.t52 109.174
R4849 XFE_E.XN.n4 XFE_E.XN.t53 109.174
R4850 XFE_E.XN.n2 XFE_E.XN.t51 109.174
R4851 XFE_E.XN.n17 XFE_E.XN.t48 109.174
R4852 XFE_E.XN.n18 XFE_E.XN.t47 109.174
R4853 XFE_E.XN.n15 XFE_E.XN.t46 109.174
R4854 XFE_E.XN.n46 XFE_E.XN.n45 26.5957
R4855 XFE_E.XN.n23 XFE_E.XN.n22 23.1457
R4856 XFE_E.XN XFE_E.XN.n5 19.3505
R4857 XFE_E.XN.n5 XFE_E.XN.n4 18.5179
R4858 XFE_E.XN.n20 XFE_E.XN.n15 18.5179
R4859 XFE_E.XN.n69 XFE_E.XN.n68 18.4942
R4860 XFE_E.XN.n74 XFE_E.XN.n73 18.4942
R4861 XFE_E.XN.n75 XFE_E.XN.n47 18.4942
R4862 XFE_E.XN.n62 XFE_E.XN.n53 18.4942
R4863 XFE_E.XN.n63 XFE_E.XN.n52 18.4942
R4864 XFE_E.XN.n64 XFE_E.XN.n51 18.4942
R4865 XFE_E.XN.n66 XFE_E.XN.n65 18.4942
R4866 XFE_E.XN.n67 XFE_E.XN.n50 18.4942
R4867 XFE_E.XN.n3 XFE_E.XN.n0 18.4942
R4868 XFE_E.XN.n19 XFE_E.XN.n18 18.4942
R4869 XFE_E.XN.n37 XFE_E.XN.n36 16.357
R4870 XFE_E.XN.n21 XFE_E.XN.n14 15.2222
R4871 XFE_E.XN.n21 XFE_E.XN.n20 14.6157
R4872 XFE_E.XN.n44 XFE_E.XN.n43 12.757
R4873 XFE_E.XN.n35 XFE_E.XN.n34 12.0135
R4874 XFE_E.XN.n75 XFE_E.XN.n74 11.6805
R4875 XFE_E.XN.n74 XFE_E.XN.n70 11.6805
R4876 XFE_E.XN.n75 XFE_E.XN.n69 11.6805
R4877 XFE_E.XN.n62 XFE_E.XN.n61 11.6805
R4878 XFE_E.XN.n63 XFE_E.XN.n62 11.6805
R4879 XFE_E.XN.n64 XFE_E.XN.n63 11.6805
R4880 XFE_E.XN.n65 XFE_E.XN.n64 11.6805
R4881 XFE_E.XN.n65 XFE_E.XN.n50 11.6805
R4882 XFE_E.XN.n69 XFE_E.XN.n50 11.6805
R4883 XFE_E.XN.n3 XFE_E.XN.n2 11.6805
R4884 XFE_E.XN.n4 XFE_E.XN.n3 11.6805
R4885 XFE_E.XN.n18 XFE_E.XN.n17 11.6805
R4886 XFE_E.XN.n18 XFE_E.XN.n15 11.6805
R4887 XFE_E.XN.n77 XFE_E.XN.n47 10.8396
R4888 XFE_E.XN.n77 XFE_E.XN.n76 9.0005
R4889 XFE_E.XN.n78 XFE_E.XN.n77 7.22007
R4890 XFE_E.XN.n73 XFE_E.XN.n72 7.17687
R4891 XFE_E.XN.n60 XFE_E.XN.n53 7.17687
R4892 XFE_E.XN.n1 XFE_E.XN.n0 7.17687
R4893 XFE_E.XN.n19 XFE_E.XN.n16 7.17687
R4894 XFE_E.XN.n25 XFE_E.XN.t8 5.7796
R4895 XFE_E.XN.n29 XFE_E.XN.t10 5.7796
R4896 XFE_E.XN.n7 XFE_E.XN.t28 5.73764
R4897 XFE_E.XN.n36 XFE_E.XN.t9 5.73764
R4898 XFE_E.XN.n14 XFE_E.XN.t19 5.6429
R4899 XFE_E.XN.n36 XFE_E.XN.t31 5.54817
R4900 XFE_E.XN.n40 XFE_E.XN.n38 5.51014
R4901 XFE_E.XN.n43 XFE_E.XN.n42 5.51014
R4902 XFE_E.XN.n25 XFE_E.XN.n24 5.38537
R4903 XFE_E.XN.n27 XFE_E.XN.n26 5.38537
R4904 XFE_E.XN.n33 XFE_E.XN.n32 5.38537
R4905 XFE_E.XN.n31 XFE_E.XN.n30 5.38537
R4906 XFE_E.XN.n29 XFE_E.XN.n28 5.38537
R4907 XFE_E.XN.n40 XFE_E.XN.n39 5.32067
R4908 XFE_E.XN.n43 XFE_E.XN.n41 5.32067
R4909 XFE_E.XN.n7 XFE_E.XN.n6 5.32067
R4910 XFE_E.XN.n9 XFE_E.XN.n8 5.32067
R4911 XFE_E.XN.n11 XFE_E.XN.n10 5.32067
R4912 XFE_E.XN.n13 XFE_E.XN.n12 5.32067
R4913 XFE_E.XN.n72 XFE_E.XN.n70 4.42851
R4914 XFE_E.XN.n61 XFE_E.XN.n60 4.42851
R4915 XFE_E.XN.n2 XFE_E.XN.n1 4.42851
R4916 XFE_E.XN.n17 XFE_E.XN.n16 4.42851
R4917 XFE_E.XN.n37 XFE_E.XN.n35 2.93528
R4918 XFE_E.XN.n78 XFE_E.XN.n46 2.93528
R4919 XFE_E.XN.n46 XFE_E.XN.n44 1.72224
R4920 XFE_E.XN.n44 XFE_E.XN.n37 1.64398
R4921 XFE_E.XN.n35 XFE_E.XN.n23 1.33093
R4922 XFE_E.XN XFE_E.XN.n78 0.743978
R4923 XFE_E.XN.n23 XFE_E.XN.n21 0.391804
R4924 XFE_E.XN.n38 XFE_E.XN.t30 0.228
R4925 XFE_E.XN.n38 XFE_E.XN.t13 0.228
R4926 XFE_E.XN.n39 XFE_E.XN.t15 0.228
R4927 XFE_E.XN.n39 XFE_E.XN.t29 0.228
R4928 XFE_E.XN.n41 XFE_E.XN.t17 0.228
R4929 XFE_E.XN.n41 XFE_E.XN.t14 0.228
R4930 XFE_E.XN.n42 XFE_E.XN.t18 0.228
R4931 XFE_E.XN.n42 XFE_E.XN.t16 0.228
R4932 XFE_E.XN.n6 XFE_E.XN.t26 0.228
R4933 XFE_E.XN.n6 XFE_E.XN.t27 0.228
R4934 XFE_E.XN.n8 XFE_E.XN.t24 0.228
R4935 XFE_E.XN.n8 XFE_E.XN.t25 0.228
R4936 XFE_E.XN.n10 XFE_E.XN.t22 0.228
R4937 XFE_E.XN.n10 XFE_E.XN.t23 0.228
R4938 XFE_E.XN.n12 XFE_E.XN.t20 0.228
R4939 XFE_E.XN.n12 XFE_E.XN.t21 0.228
R4940 XFE_E.XN.n24 XFE_E.XN.t12 0.20525
R4941 XFE_E.XN.n24 XFE_E.XN.t11 0.20525
R4942 XFE_E.XN.n26 XFE_E.XN.t7 0.20525
R4943 XFE_E.XN.n26 XFE_E.XN.t6 0.20525
R4944 XFE_E.XN.n32 XFE_E.XN.t1 0.20525
R4945 XFE_E.XN.n32 XFE_E.XN.t0 0.20525
R4946 XFE_E.XN.n30 XFE_E.XN.t3 0.20525
R4947 XFE_E.XN.n30 XFE_E.XN.t2 0.20525
R4948 XFE_E.XN.n28 XFE_E.XN.t5 0.20525
R4949 XFE_E.XN.n28 XFE_E.XN.t4 0.20525
R4950 XFE_E.XN.n13 XFE_E.XN.n11 0.189974
R4951 XFE_E.XN.n11 XFE_E.XN.n9 0.189974
R4952 XFE_E.XN.n9 XFE_E.XN.n7 0.189974
R4953 XFE_E.XN.n43 XFE_E.XN.n40 0.189974
R4954 XFE_E.XN.n31 XFE_E.XN.n29 0.189974
R4955 XFE_E.XN.n33 XFE_E.XN.n31 0.189974
R4956 XFE_E.XN.n27 XFE_E.XN.n25 0.189974
R4957 XFE_E.XN.n68 XFE_E.XN.n67 0.1205
R4958 XFE_E.XN.n67 XFE_E.XN.n66 0.1205
R4959 XFE_E.XN.n66 XFE_E.XN.n51 0.1205
R4960 XFE_E.XN.n52 XFE_E.XN.n51 0.1205
R4961 XFE_E.XN.n53 XFE_E.XN.n52 0.1205
R4962 XFE_E.XN.n54 XFE_E.XN.n48 0.1205
R4963 XFE_E.XN.n55 XFE_E.XN.n54 0.1205
R4964 XFE_E.XN.n56 XFE_E.XN.n55 0.1205
R4965 XFE_E.XN.n57 XFE_E.XN.n56 0.1205
R4966 XFE_E.XN.n58 XFE_E.XN.n57 0.1205
R4967 XFE_E.XN.n59 XFE_E.XN.n58 0.1205
R4968 XFE_E.XN.n71 XFE_E.XN.n49 0.1205
R4969 XFE_E.XN.n68 XFE_E.XN.n47 0.1085
R4970 XFE_E.XN.n76 XFE_E.XN.n48 0.1085
R4971 XFE_E.XN.n76 XFE_E.XN.n49 0.1085
R4972 XFE_E.XN.n73 XFE_E.XN.n47 0.1085
R4973 XFE_E.XN.n14 XFE_E.XN.n13 0.0952368
R4974 XFE_E.XN.n34 XFE_E.XN.n33 0.0952368
R4975 XFE_E.XN.n34 XFE_E.XN.n27 0.0952368
R4976 XFE_E.XN.n5 XFE_E.XN.n0 0.0785
R4977 XFE_E.XN.n20 XFE_E.XN.n19 0.0785
R4978 XFE_E.XP.t43 XFE_E.XP.n39 127.788
R4979 XFE_E.XP.t32 XFE_E.XP.n27 127.788
R4980 XFE_E.XP.t39 XFE_E.XP.n16 127.668
R4981 XFE_E.XP.n39 XFE_E.XP.t42 127.668
R4982 XFE_E.XP.t41 XFE_E.XP.n17 127.668
R4983 XFE_E.XP.n44 XFE_E.XP.t40 127.668
R4984 XFE_E.XP.n27 XFE_E.XP.t33 127.668
R4985 XFE_E.XP.n26 XFE_E.XP.t34 127.668
R4986 XFE_E.XP.n25 XFE_E.XP.t35 127.668
R4987 XFE_E.XP.n24 XFE_E.XP.t36 127.668
R4988 XFE_E.XP.n23 XFE_E.XP.t37 127.668
R4989 XFE_E.XP.n22 XFE_E.XP.t38 127.668
R4990 XFE_E.XP.n71 XFE_E.XP.t44 113.632
R4991 XFE_E.XP.n74 XFE_E.XP.t46 113.632
R4992 XFE_E.XP.n40 XFE_E.XP.t43 113.632
R4993 XFE_E.XP.n28 XFE_E.XP.t32 113.632
R4994 XFE_E.XP.n47 XFE_E.XP.t51 113.632
R4995 XFE_E.XP.n10 XFE_E.XP.t52 113.632
R4996 XFE_E.XP.n71 XFE_E.XP.t45 113.603
R4997 XFE_E.XP.n47 XFE_E.XP.t50 113.603
R4998 XFE_E.XP.n76 XFE_E.XP.t48 109.174
R4999 XFE_E.XP.n77 XFE_E.XP.t49 109.174
R5000 XFE_E.XP.n75 XFE_E.XP.t47 109.174
R5001 XFE_E.XP.n37 XFE_E.XP.t39 109.174
R5002 XFE_E.XP.t42 XFE_E.XP.n38 109.174
R5003 XFE_E.XP.n42 XFE_E.XP.t41 109.174
R5004 XFE_E.XP.t40 XFE_E.XP.n43 109.174
R5005 XFE_E.XP.n29 XFE_E.XP.t33 109.174
R5006 XFE_E.XP.n30 XFE_E.XP.t34 109.174
R5007 XFE_E.XP.n31 XFE_E.XP.t35 109.174
R5008 XFE_E.XP.n32 XFE_E.XP.t36 109.174
R5009 XFE_E.XP.n33 XFE_E.XP.t37 109.174
R5010 XFE_E.XP.t38 XFE_E.XP.n18 109.174
R5011 XFE_E.XP.n13 XFE_E.XP.t55 109.174
R5012 XFE_E.XP.n12 XFE_E.XP.t54 109.174
R5013 XFE_E.XP.n11 XFE_E.XP.t53 109.174
R5014 XFE_E.XP.n48 XFE_E.XP.n47 26.8696
R5015 XFE_E.XP.n72 XFE_E.XP.n71 22.8718
R5016 XFE_E.XP.n46 XFE_E.XP.n14 20.2802
R5017 XFE_E.XP.n78 XFE_E.XP.n77 18.5179
R5018 XFE_E.XP.n76 XFE_E.XP.n73 18.4942
R5019 XFE_E.XP.n37 XFE_E.XP.n36 18.4942
R5020 XFE_E.XP.n42 XFE_E.XP.n41 18.4942
R5021 XFE_E.XP.n43 XFE_E.XP.n15 18.4942
R5022 XFE_E.XP.n30 XFE_E.XP.n21 18.4942
R5023 XFE_E.XP.n31 XFE_E.XP.n20 18.4942
R5024 XFE_E.XP.n32 XFE_E.XP.n19 18.4942
R5025 XFE_E.XP.n34 XFE_E.XP.n33 18.4942
R5026 XFE_E.XP.n35 XFE_E.XP.n18 18.4942
R5027 XFE_E.XP.n14 XFE_E.XP.n13 18.4942
R5028 XFE_E.XP.n12 XFE_E.XP.n9 18.4942
R5029 XFE_E.XP.n58 XFE_E.XP.n57 16.6309
R5030 XFE_E.XP.n79 XFE_E.XP.n78 14.8896
R5031 XFE_E.XP XFE_E.XP.n8 14.3222
R5032 XFE_E.XP.n56 XFE_E.XP.n55 14.2831
R5033 XFE_E.XP.n70 XFE_E.XP.n69 11.7396
R5034 XFE_E.XP.n76 XFE_E.XP.n75 11.6805
R5035 XFE_E.XP.n77 XFE_E.XP.n76 11.6805
R5036 XFE_E.XP.n43 XFE_E.XP.n42 11.6805
R5037 XFE_E.XP.n42 XFE_E.XP.n38 11.6805
R5038 XFE_E.XP.n43 XFE_E.XP.n37 11.6805
R5039 XFE_E.XP.n30 XFE_E.XP.n29 11.6805
R5040 XFE_E.XP.n31 XFE_E.XP.n30 11.6805
R5041 XFE_E.XP.n32 XFE_E.XP.n31 11.6805
R5042 XFE_E.XP.n33 XFE_E.XP.n32 11.6805
R5043 XFE_E.XP.n33 XFE_E.XP.n18 11.6805
R5044 XFE_E.XP.n37 XFE_E.XP.n18 11.6805
R5045 XFE_E.XP.n13 XFE_E.XP.n12 11.6805
R5046 XFE_E.XP.n12 XFE_E.XP.n11 11.6805
R5047 XFE_E.XP.n45 XFE_E.XP.n15 10.8396
R5048 XFE_E.XP.n45 XFE_E.XP.n44 9.0005
R5049 XFE_E.XP.n74 XFE_E.XP.n73 7.17687
R5050 XFE_E.XP.n41 XFE_E.XP.n40 7.17687
R5051 XFE_E.XP.n28 XFE_E.XP.n21 7.17687
R5052 XFE_E.XP.n10 XFE_E.XP.n9 7.17687
R5053 XFE_E.XP.n46 XFE_E.XP.n45 6.94615
R5054 XFE_E.XP.n60 XFE_E.XP.t11 5.7796
R5055 XFE_E.XP.n64 XFE_E.XP.t0 5.7796
R5056 XFE_E.XP.n1 XFE_E.XP.t14 5.73764
R5057 XFE_E.XP.n50 XFE_E.XP.t31 5.73764
R5058 XFE_E.XP.n52 XFE_E.XP.t24 5.73764
R5059 XFE_E.XP.n57 XFE_E.XP.t13 5.66659
R5060 XFE_E.XP.n57 XFE_E.XP.t12 5.61922
R5061 XFE_E.XP.n8 XFE_E.XP.t23 5.57185
R5062 XFE_E.XP.n60 XFE_E.XP.n59 5.38537
R5063 XFE_E.XP.n62 XFE_E.XP.n61 5.38537
R5064 XFE_E.XP.n68 XFE_E.XP.n67 5.38537
R5065 XFE_E.XP.n66 XFE_E.XP.n65 5.38537
R5066 XFE_E.XP.n64 XFE_E.XP.n63 5.38537
R5067 XFE_E.XP.n7 XFE_E.XP.n6 5.32067
R5068 XFE_E.XP.n5 XFE_E.XP.n4 5.32067
R5069 XFE_E.XP.n3 XFE_E.XP.n2 5.32067
R5070 XFE_E.XP.n1 XFE_E.XP.n0 5.32067
R5071 XFE_E.XP.n50 XFE_E.XP.n49 5.32067
R5072 XFE_E.XP.n54 XFE_E.XP.n53 5.32067
R5073 XFE_E.XP.n52 XFE_E.XP.n51 5.32067
R5074 XFE_E.XP.n75 XFE_E.XP.n74 4.42851
R5075 XFE_E.XP.n40 XFE_E.XP.n38 4.42851
R5076 XFE_E.XP.n29 XFE_E.XP.n28 4.42851
R5077 XFE_E.XP.n11 XFE_E.XP.n10 4.42851
R5078 XFE_E.XP.n48 XFE_E.XP.n46 3.71789
R5079 XFE_E.XP.n70 XFE_E.XP.n58 3.13093
R5080 XFE_E.XP.n58 XFE_E.XP.n56 1.76137
R5081 XFE_E.XP.n56 XFE_E.XP.n48 1.72224
R5082 XFE_E.XP XFE_E.XP.n79 1.2918
R5083 XFE_E.XP.n72 XFE_E.XP.n70 1.01789
R5084 XFE_E.XP.n79 XFE_E.XP.n72 0.391804
R5085 XFE_E.XP.n6 XFE_E.XP.t21 0.228
R5086 XFE_E.XP.n6 XFE_E.XP.t22 0.228
R5087 XFE_E.XP.n4 XFE_E.XP.t19 0.228
R5088 XFE_E.XP.n4 XFE_E.XP.t20 0.228
R5089 XFE_E.XP.n2 XFE_E.XP.t17 0.228
R5090 XFE_E.XP.n2 XFE_E.XP.t18 0.228
R5091 XFE_E.XP.n0 XFE_E.XP.t15 0.228
R5092 XFE_E.XP.n0 XFE_E.XP.t16 0.228
R5093 XFE_E.XP.n49 XFE_E.XP.t29 0.228
R5094 XFE_E.XP.n49 XFE_E.XP.t30 0.228
R5095 XFE_E.XP.n53 XFE_E.XP.t27 0.228
R5096 XFE_E.XP.n53 XFE_E.XP.t28 0.228
R5097 XFE_E.XP.n51 XFE_E.XP.t25 0.228
R5098 XFE_E.XP.n51 XFE_E.XP.t26 0.228
R5099 XFE_E.XP.n59 XFE_E.XP.t9 0.20525
R5100 XFE_E.XP.n59 XFE_E.XP.t10 0.20525
R5101 XFE_E.XP.n61 XFE_E.XP.t7 0.20525
R5102 XFE_E.XP.n61 XFE_E.XP.t8 0.20525
R5103 XFE_E.XP.n67 XFE_E.XP.t5 0.20525
R5104 XFE_E.XP.n67 XFE_E.XP.t6 0.20525
R5105 XFE_E.XP.n65 XFE_E.XP.t3 0.20525
R5106 XFE_E.XP.n65 XFE_E.XP.t4 0.20525
R5107 XFE_E.XP.n63 XFE_E.XP.t1 0.20525
R5108 XFE_E.XP.n63 XFE_E.XP.t2 0.20525
R5109 XFE_E.XP.n66 XFE_E.XP.n64 0.189974
R5110 XFE_E.XP.n68 XFE_E.XP.n66 0.189974
R5111 XFE_E.XP.n62 XFE_E.XP.n60 0.189974
R5112 XFE_E.XP.n3 XFE_E.XP.n1 0.189974
R5113 XFE_E.XP.n5 XFE_E.XP.n3 0.189974
R5114 XFE_E.XP.n7 XFE_E.XP.n5 0.189974
R5115 XFE_E.XP.n54 XFE_E.XP.n52 0.189974
R5116 XFE_E.XP.n8 XFE_E.XP.n7 0.166289
R5117 XFE_E.XP.n36 XFE_E.XP.n35 0.1205
R5118 XFE_E.XP.n35 XFE_E.XP.n34 0.1205
R5119 XFE_E.XP.n34 XFE_E.XP.n19 0.1205
R5120 XFE_E.XP.n20 XFE_E.XP.n19 0.1205
R5121 XFE_E.XP.n21 XFE_E.XP.n20 0.1205
R5122 XFE_E.XP.n22 XFE_E.XP.n16 0.1205
R5123 XFE_E.XP.n23 XFE_E.XP.n22 0.1205
R5124 XFE_E.XP.n24 XFE_E.XP.n23 0.1205
R5125 XFE_E.XP.n25 XFE_E.XP.n24 0.1205
R5126 XFE_E.XP.n26 XFE_E.XP.n25 0.1205
R5127 XFE_E.XP.n27 XFE_E.XP.n26 0.1205
R5128 XFE_E.XP.n39 XFE_E.XP.n17 0.1205
R5129 XFE_E.XP.n14 XFE_E.XP.n9 0.1205
R5130 XFE_E.XP.n36 XFE_E.XP.n15 0.1085
R5131 XFE_E.XP.n44 XFE_E.XP.n16 0.1085
R5132 XFE_E.XP.n44 XFE_E.XP.n17 0.1085
R5133 XFE_E.XP.n41 XFE_E.XP.n15 0.1085
R5134 XFE_E.XP.n69 XFE_E.XP.n68 0.0952368
R5135 XFE_E.XP.n69 XFE_E.XP.n62 0.0952368
R5136 XFE_E.XP.n55 XFE_E.XP.n54 0.0952368
R5137 XFE_E.XP.n55 XFE_E.XP.n50 0.0952368
R5138 XFE_E.XP.n78 XFE_E.XP.n73 0.0785
C0 TERM_EN3_N TERM_EN2_N 0.0465f
C1 XFE_O.HB VDD 16.1006f
C2 VTHP VTHN 0.71747f
C3 XFE_O.DN O_SENSE_CLK 0.18071f
C4 XFE_E.XN VDD 25.3962f
C5 XFE_O.NTAIL RX_RAWN 1.55309f
C6 XFE_E.HB XFE_E.H 7.51355f
C7 XFE_E.H XFE_E.NIP 0.07683f
C8 XFE_O.XP XFE_O.NIN 2.21087f
C9 VTHN VDD 0.44639f
C10 RXP TERM_EN2_N 0.3225f
C11 XFE_E.NTAIL RX_RAWN 2.27268f
C12 XFE_E.H XFE_E.NIN 0.07808f
C13 XFE_O.XN XFE_O.NIN 14.5465f
C14 XFE_E.HB XFE_E.NIP 0.07069f
C15 XFE_O.XP XFE_O.NIP 14.4614f
C16 XFE_E.XN XFE_E.DN 2.15469f
C17 RX_RAWP O_SENSE_BOOST 0.07703f
C18 XFE_O.HB XFE_O.NIN 0.07207f
C19 TERM_EN2_N TERM_EN1_N 0.0465f
C20 XFE_E.HB XFE_E.NIN 0.07207f
C21 XFE_O.XN XFE_O.NIP 2.86849f
C22 XFE_O.HB XFE_O.NIP 0.07069f
C23 XFE_E.XN XFE_E.H 1.91259f
C24 RXP TERM_EN0_N 0.29398f
C25 VTHN RX_BW_EN_N 0.14867f
C26 XFE_O.XN XFE_O.XP 22.8576f
C27 XFE_E.XN XFE_E.HB 0.56886f
C28 TERM_EN5_N VDD 1.84084f
C29 XFE_E.XN XFE_E.NIP 2.86849f
C30 XFE_O.XP XFE_O.HB 3.58406f
C31 TERM_EN1_N TERM_EN0_N 0.0465f
C32 XFE_O.H RX_RAWP 0.01013f
C33 VDD E_SENSE_CLK 21.2686f
C34 XFE_E.DP E_SENSE_CLK 0.29923f
C35 E_SENSE_CLK E_SENSE_BOOST 6.47808f
C36 XFE_E.XN XFE_E.NIN 14.5465f
C37 XFE_O.XN XFE_O.HB 0.56886f
C38 VDD E_CAPTURE_CLKB 0.11029f
C39 XFE_E.DN E_SENSE_CLK 0.18071f
C40 TERM_EN3_N VDD 1.84084f
C41 VDD FE_E_P 5.28554f
C42 XFE_E.H E_SENSE_CLK 1.23646f
C43 O_SENSE_CLK O_SENSE_BOOST 6.47808f
C44 VDD O_REGEN_CLKB 0.13321f
C45 RXP VDD 0.72204f
C46 XFE_E.HB E_SENSE_CLK 2.31435f
C47 XFE_E.NIP E_SENSE_CLK 2.64521f
C48 TERM_EN1_N VDD 1.84084f
C49 XFE_E.NTAIL E_SENSE_BOOST 5.37348f
C50 VDD XFE_O.DN 6.18388f
C51 XFE_E.NIN E_SENSE_CLK 2.60237f
C52 RX_RAWN O_SENSE_BOOST 0.07735f
C53 XFE_O.NIN XFE_O.NTAIL 10.6347f
C54 XFE_O.H O_SENSE_CLK 1.23646f
C55 VDD O_CAPTURE_CLKB 0.11029f
C56 VDD FE_E_N 5.18923f
C57 XFE_E.HB FE_E_P 1.39766f
C58 XFE_O.NIP XFE_O.NTAIL 10.1886f
C59 XFE_E.XN E_SENSE_CLK 5.09008f
C60 E_REGEN_CLKB FE_E_P 0.02948f
C61 O_REGEN_CLK FE_O_N 0.01097f
C62 O_SENSE_CLK RX_RAWP 0.40197f
C63 XFE_O.H RX_RAWN 0.01013f
C64 XFE_E.NIP XFE_E.NTAIL 10.1886f
C65 XFE_E.H FE_E_N 1.28169f
C66 XFE_E.NIN XFE_E.NTAIL 10.6347f
C67 XFE_O.XP XFE_O.DN 0.04432f
C68 VDD FE_O_P 5.18923f
C69 RX_RAWP RX_RAWN 12.717f
C70 XFE_O.XN XFE_O.DN 2.15469f
C71 XFE_O.HB XFE_O.DN 2.12721f
C72 VDD FE_O_N 5.28554f
C73 RXP TERM_EN5_N 0.3225f
C74 XFE_O.H XFE_O.DP 2.1383f
C75 XFE_O.NIN O_SENSE_BOOST 0.0301f
C76 RX_BIAS RXP 0.89265f
C77 XFE_E.NTAIL E_SENSE_CLK 1.32172f
C78 XFE_O.H VDD 16.7985f
C79 O_SENSE_CLK RX_RAWN 5.46787f
C80 XFE_O.NIP O_SENSE_BOOST 0.21857f
C81 RXP TERM_EN3_N 0.3225f
C82 VDD RX_RAWP 1.46674f
C83 XFE_O.H XFE_O.NIN 0.07808f
C84 RX_RAWP E_SENSE_BOOST 0.07735f
C85 XFE_O.H XFE_O.NIP 0.07683f
C86 RXP TERM_EN1_N 0.30522f
C87 XFE_O.HB FE_O_N 1.39766f
C88 XFE_O.XP XFE_O.H 0.82467f
C89 XFE_E.H RX_RAWP 0.01013f
C90 RX_RAWP RX_BW_EN_N 0.3734f
C91 TERM_EN6_N VDD 1.78028f
C92 XFE_O.NIP RX_RAWP 1.58284f
C93 XFE_O.XN XFE_O.H 1.91259f
C94 XFE_O.H XFE_O.HB 7.51355f
C95 VDD E_REGEN_CLK 0.13916f
C96 XFE_E.NIN RX_RAWP 2.30328f
C97 XFE_O.DP O_SENSE_CLK 0.29923f
C98 TERM_EN4_N VDD 1.84084f
C99 VDD O_SENSE_CLK 21.2686f
C100 RX_BIAS RXN 0.36689f
C101 VDD E_CAPTURE_CLK 0.11494f
C102 VDD XFE_E.XP 25.819f
C103 VDD RX_RAWN 1.37416f
C104 TERM_EN2_N VDD 1.84084f
C105 XFE_E.DP XFE_E.XP 2.21809f
C106 XFE_O.NIN O_SENSE_CLK 2.60237f
C107 RX_RAWN E_SENSE_BOOST 0.07703f
C108 XFE_E.DN XFE_E.XP 0.04432f
C109 XFE_O.NIP O_SENSE_CLK 2.64521f
C110 VDD O_REGEN_CLK 0.13916f
C111 XFE_O.NTAIL O_SENSE_BOOST 5.37348f
C112 RXP RXN 0.4911f
C113 XFE_O.NIN RX_RAWN 2.30328f
C114 TERM_EN0_N VDD 1.71963f
C115 XFE_E.H XFE_E.XP 0.82467f
C116 XFE_O.XP O_SENSE_CLK 5.70356f
C117 O_REGEN_CLKB FE_O_N 0.02948f
C118 XFE_E.H RX_RAWN 0.01013f
C119 RX_RAWN RX_BW_EN_N 0.35734f
C120 E_SENSE_CLK RX_RAWP 5.46787f
C121 XFE_E.HB XFE_E.XP 3.58406f
C122 XFE_O.XN O_SENSE_CLK 5.09008f
C123 VDD O_CAPTURE_CLK 0.11494f
C124 XFE_E.NIP XFE_E.XP 14.4614f
C125 XFE_O.HB O_SENSE_CLK 2.31435f
C126 XFE_E.NIP RX_RAWN 1.58284f
C127 XFE_E.NIN XFE_E.XP 2.21087f
C128 TERM_EN6_N TERM_EN5_N 0.0465f
C129 XFE_O.H XFE_O.DN 0.66623f
C130 VTHP VDD 0.44639f
C131 XFE_O.NTAIL RX_RAWP 2.27268f
C132 XFE_E.XN XFE_E.XP 22.8576f
C133 XFE_O.DP VDD 6.18171f
C134 XFE_E.NTAIL RX_RAWP 1.55309f
C135 XFE_E.DP VDD 6.18171f
C136 TERM_EN5_N TERM_EN4_N 0.0465f
C137 XFE_E.DN VDD 6.18388f
C138 VTHP RX_BW_EN_N 0.14867f
C139 XFE_O.NIN VDD 6.7829f
C140 E_REGEN_CLK FE_E_P 0.01097f
C141 RXP TERM_EN6_N 0.32905f
C142 XFE_E.H VDD 16.7985f
C143 VDD RX_BW_EN_N 3.18648f
C144 XFE_O.NIP VDD 6.70406f
C145 E_SENSE_CLK XFE_E.XP 5.70356f
C146 XFE_E.H XFE_E.DP 2.1383f
C147 TERM_EN4_N TERM_EN3_N 0.0465f
C148 XFE_O.H FE_O_P 1.28169f
C149 E_SENSE_CLK RX_RAWN 0.40197f
C150 XFE_E.HB VDD 16.1006f
C151 XFE_E.NIP VDD 6.70406f
C152 XFE_O.XP XFE_O.DP 2.21809f
C153 XFE_E.HB XFE_E.DP 0.75819f
C154 XFE_E.H XFE_E.DN 0.66623f
C155 VDD E_REGEN_CLKB 0.13321f
C156 XFE_O.NTAIL O_SENSE_CLK 1.32172f
C157 XFE_E.NIP E_SENSE_BOOST 0.21857f
C158 XFE_O.XP VDD 25.819f
C159 XFE_E.NIN VDD 6.7829f
C160 RXP TERM_EN4_N 0.3225f
C161 XFE_E.HB XFE_E.DN 2.12721f
C162 XFE_O.HB XFE_O.DP 0.75819f
C163 XFE_E.NIN E_SENSE_BOOST 0.0301f
C164 XFE_O.XN VDD 25.3962f
C165 O_CAPTURE_CLK VSS 0.14352f
C166 O_CAPTURE_CLKB VSS 0.14766f
C167 O_REGEN_CLK VSS 0.10547f
C168 O_REGEN_CLKB VSS 0.09145f
C169 E_CAPTURE_CLK VSS 0.14352f
C170 E_CAPTURE_CLKB VSS 0.14766f
C171 E_REGEN_CLK VSS 0.10547f
C172 E_REGEN_CLKB VSS 0.09145f
C173 TERM_EN0_N VSS 3.16281f
C174 TERM_EN1_N VSS 2.58106f
C175 TERM_EN2_N VSS 2.56583f
C176 TERM_EN3_N VSS 2.56561f
C177 TERM_EN4_N VSS 2.56561f
C178 TERM_EN5_N VSS 2.56561f
C179 TERM_EN6_N VSS 2.69513f
C180 RXN VSS 15.23621f
C181 RXP VSS 15.16766f
C182 RX_BIAS VSS 13.3368f
C183 VTHN VSS 2.67742f
C184 VTHP VSS 2.67769f
C185 RX_BW_EN_N VSS 3.53422f
C186 O_SENSE_BOOST VSS 19.08508f
C187 E_SENSE_BOOST VSS 19.08508f
C188 RX_RAWN VSS 26.45293f
C189 RX_RAWP VSS 26.37508f
C190 FE_O_N VSS 7.39491f
C191 FE_O_P VSS 7.49786f
C192 FE_E_N VSS 7.49786f
C193 FE_E_P VSS 7.39491f
C194 O_SENSE_CLK VSS 17.67546f
C195 E_SENSE_CLK VSS 17.67546f
C196 VDD VSS 3.17905p
C197 XFE_O.NTAIL VSS 46.98668f
C198 XFE_E.NTAIL VSS 47.47016f
C199 XFE_O.DN VSS 9.84723f
C200 XFE_O.DP VSS 9.85739f
C201 XFE_E.DP VSS 10.10227f
C202 XFE_E.DN VSS 10.19211f
C203 XFE_O.NIN VSS 3.76356f
C204 XFE_O.NIP VSS 3.47617f
C205 XFE_E.NIP VSS 4.35051f
C206 XFE_E.NIN VSS 5.165f
C207 XFE_O.HB VSS 19.64067f
C208 XFE_O.H VSS 20.30146f
C209 XFE_E.H VSS 20.61385f
C210 XFE_E.HB VSS 20.35346f
C211 XFE_O.XP VSS 10.75778f
C212 XFE_O.XN VSS 11.15447f
C213 XFE_E.XN VSS 13.06891f
C214 XFE_E.XP VSS 12.33217f
C215 XFE_E.XP.t23 VSS 1.38791f
C216 XFE_E.XP.t14 VSS 1.3992f
C217 XFE_E.XP.t16 VSS 0.29876f
C218 XFE_E.XP.t15 VSS 0.29876f
C219 XFE_E.XP.n0 VSS 1.05643f
C220 XFE_E.XP.n1 VSS 0.58069f
C221 XFE_E.XP.t18 VSS 0.29876f
C222 XFE_E.XP.t17 VSS 0.29876f
C223 XFE_E.XP.n2 VSS 1.05643f
C224 XFE_E.XP.n3 VSS 0.30313f
C225 XFE_E.XP.t20 VSS 0.29876f
C226 XFE_E.XP.t19 VSS 0.29876f
C227 XFE_E.XP.n4 VSS 1.05643f
C228 XFE_E.XP.n5 VSS 0.30313f
C229 XFE_E.XP.t22 VSS 0.29876f
C230 XFE_E.XP.t21 VSS 0.29876f
C231 XFE_E.XP.n6 VSS 1.05643f
C232 XFE_E.XP.n7 VSS 0.28822f
C233 XFE_E.XP.n8 VSS 1.55768f
C234 XFE_E.XP.n9 VSS 0.33737f
C235 XFE_E.XP.n10 VSS 0.16675f
C236 XFE_E.XP.n11 VSS 0.17874f
C237 XFE_E.XP.n12 VSS 0.17874f
C238 XFE_E.XP.n13 VSS 0.16893f
C239 XFE_E.XP.n14 VSS 1.42089f
C240 XFE_E.XP.n15 VSS 0.24239f
C241 XFE_E.XP.n16 VSS 0.25025f
C242 XFE_E.XP.n17 VSS 0.25025f
C243 XFE_E.XP.n18 VSS 0.17874f
C244 XFE_E.XP.n19 VSS 0.11591f
C245 XFE_E.XP.n20 VSS 0.11591f
C246 XFE_E.XP.n21 VSS 0.33737f
C247 XFE_E.XP.n22 VSS 0.25051f
C248 XFE_E.XP.n23 VSS 0.25051f
C249 XFE_E.XP.n24 VSS 0.25051f
C250 XFE_E.XP.n25 VSS 0.25051f
C251 XFE_E.XP.n26 VSS 0.25051f
C252 XFE_E.XP.n27 VSS 0.4949f
C253 XFE_E.XP.n28 VSS 0.16675f
C254 XFE_E.XP.n29 VSS 0.17874f
C255 XFE_E.XP.n30 VSS 0.17874f
C256 XFE_E.XP.n31 VSS 0.17874f
C257 XFE_E.XP.n32 VSS 0.17874f
C258 XFE_E.XP.n33 VSS 0.17874f
C259 XFE_E.XP.n34 VSS 0.11591f
C260 XFE_E.XP.n35 VSS 0.11591f
C261 XFE_E.XP.n36 VSS 0.11565f
C262 XFE_E.XP.n37 VSS 0.17874f
C263 XFE_E.XP.n38 VSS 0.17874f
C264 XFE_E.XP.n39 VSS 0.4949f
C265 XFE_E.XP.n40 VSS 0.16675f
C266 XFE_E.XP.n41 VSS 0.3371f
C267 XFE_E.XP.n42 VSS 0.17874f
C268 XFE_E.XP.n43 VSS 0.17874f
C269 XFE_E.XP.n44 VSS 0.29566f
C270 XFE_E.XP.n45 VSS 1.795f
C271 XFE_E.XP.n46 VSS 3.10172f
C272 XFE_E.XP.n47 VSS 1.47542f
C273 XFE_E.XP.n48 VSS 3.45737f
C274 XFE_E.XP.t31 VSS 1.3992f
C275 XFE_E.XP.t30 VSS 0.29876f
C276 XFE_E.XP.t29 VSS 0.29876f
C277 XFE_E.XP.n49 VSS 1.05643f
C278 XFE_E.XP.n50 VSS 0.52103f
C279 XFE_E.XP.t24 VSS 1.39919f
C280 XFE_E.XP.t26 VSS 0.29876f
C281 XFE_E.XP.t25 VSS 0.29876f
C282 XFE_E.XP.n51 VSS 1.05643f
C283 XFE_E.XP.n52 VSS 0.58069f
C284 XFE_E.XP.t28 VSS 0.29876f
C285 XFE_E.XP.t27 VSS 0.29876f
C286 XFE_E.XP.n53 VSS 1.05643f
C287 XFE_E.XP.n54 VSS 0.24348f
C288 XFE_E.XP.n55 VSS 1.37228f
C289 XFE_E.XP.n56 VSS 2.05638f
C290 XFE_E.XP.t13 VSS 1.47571f
C291 XFE_E.XP.t12 VSS 1.47329f
C292 XFE_E.XP.n57 VSS 2.36091f
C293 XFE_E.XP.n58 VSS 2.92298f
C294 XFE_E.XP.t11 VSS 1.43044f
C295 XFE_E.XP.t10 VSS 0.33163f
C296 XFE_E.XP.t9 VSS 0.33163f
C297 XFE_E.XP.n59 VSS 1.04864f
C298 XFE_E.XP.n60 VSS 0.591f
C299 XFE_E.XP.t8 VSS 0.33163f
C300 XFE_E.XP.t7 VSS 0.33163f
C301 XFE_E.XP.n61 VSS 1.04864f
C302 XFE_E.XP.n62 VSS 0.25126f
C303 XFE_E.XP.t0 VSS 1.43044f
C304 XFE_E.XP.t2 VSS 0.33163f
C305 XFE_E.XP.t1 VSS 0.33163f
C306 XFE_E.XP.n63 VSS 1.04864f
C307 XFE_E.XP.n64 VSS 0.591f
C308 XFE_E.XP.t4 VSS 0.33163f
C309 XFE_E.XP.t3 VSS 0.33163f
C310 XFE_E.XP.n65 VSS 1.04864f
C311 XFE_E.XP.n66 VSS 0.31092f
C312 XFE_E.XP.t6 VSS 0.33163f
C313 XFE_E.XP.t5 VSS 0.33163f
C314 XFE_E.XP.n67 VSS 1.04864f
C315 XFE_E.XP.n68 VSS 0.25126f
C316 XFE_E.XP.n69 VSS 0.78552f
C317 XFE_E.XP.n70 VSS 1.62307f
C318 XFE_E.XP.n71 VSS 0.95385f
C319 XFE_E.XP.n72 VSS 1.25315f
C320 XFE_E.XP.n73 VSS 0.32704f
C321 XFE_E.XP.n74 VSS 0.16675f
C322 XFE_E.XP.n75 VSS 0.17874f
C323 XFE_E.XP.n76 VSS 0.17874f
C324 XFE_E.XP.n77 VSS 0.16904f
C325 XFE_E.XP.n78 VSS 0.42062f
C326 XFE_E.XP.n79 VSS 0.8627f
C327 XFE_E.XN.n0 VSS 0.32954f
C328 XFE_E.XN.n1 VSS 0.16803f
C329 XFE_E.XN.n2 VSS 0.18011f
C330 XFE_E.XN.n3 VSS 0.18011f
C331 XFE_E.XN.n4 VSS 0.17033f
C332 XFE_E.XN.n5 VSS 1.24336f
C333 XFE_E.XN.t28 VSS 1.40913f
C334 XFE_E.XN.t27 VSS 0.30031f
C335 XFE_E.XN.t26 VSS 0.30031f
C336 XFE_E.XN.n6 VSS 1.06449f
C337 XFE_E.XN.n7 VSS 0.58512f
C338 XFE_E.XN.t25 VSS 0.30031f
C339 XFE_E.XN.t24 VSS 0.30031f
C340 XFE_E.XN.n8 VSS 1.06449f
C341 XFE_E.XN.n9 VSS 0.30545f
C342 XFE_E.XN.t23 VSS 0.30031f
C343 XFE_E.XN.t22 VSS 0.30031f
C344 XFE_E.XN.n10 VSS 1.06449f
C345 XFE_E.XN.n11 VSS 0.30545f
C346 XFE_E.XN.t21 VSS 0.30031f
C347 XFE_E.XN.t20 VSS 0.30031f
C348 XFE_E.XN.n12 VSS 1.06449f
C349 XFE_E.XN.n13 VSS 0.24533f
C350 XFE_E.XN.t19 VSS 1.40085f
C351 XFE_E.XN.n14 VSS 1.66511f
C352 XFE_E.XN.n15 VSS 0.17033f
C353 XFE_E.XN.n16 VSS 0.16803f
C354 XFE_E.XN.n17 VSS 0.18011f
C355 XFE_E.XN.n18 VSS 0.18011f
C356 XFE_E.XN.n19 VSS 0.32954f
C357 XFE_E.XN.n20 VSS 0.3775f
C358 XFE_E.XN.n21 VSS 2.16471f
C359 XFE_E.XN.n22 VSS 0.9973f
C360 XFE_E.XN.n23 VSS 1.42665f
C361 XFE_E.XN.t8 VSS 1.43937f
C362 XFE_E.XN.t11 VSS 0.33222f
C363 XFE_E.XN.t12 VSS 0.33222f
C364 XFE_E.XN.n24 VSS 1.05664f
C365 XFE_E.XN.n25 VSS 0.59551f
C366 XFE_E.XN.t6 VSS 0.33222f
C367 XFE_E.XN.t7 VSS 0.33222f
C368 XFE_E.XN.n26 VSS 1.05664f
C369 XFE_E.XN.n27 VSS 0.25318f
C370 XFE_E.XN.t10 VSS 1.43937f
C371 XFE_E.XN.t4 VSS 0.33222f
C372 XFE_E.XN.t5 VSS 0.33222f
C373 XFE_E.XN.n28 VSS 1.05664f
C374 XFE_E.XN.n29 VSS 0.59551f
C375 XFE_E.XN.t2 VSS 0.33222f
C376 XFE_E.XN.t3 VSS 0.33222f
C377 XFE_E.XN.n30 VSS 1.05664f
C378 XFE_E.XN.n31 VSS 0.31329f
C379 XFE_E.XN.t0 VSS 0.33222f
C380 XFE_E.XN.t1 VSS 0.33222f
C381 XFE_E.XN.n32 VSS 1.05664f
C382 XFE_E.XN.n33 VSS 0.25318f
C383 XFE_E.XN.n34 VSS 0.85518f
C384 XFE_E.XN.n35 VSS 1.72642f
C385 XFE_E.XN.t31 VSS 1.47912f
C386 XFE_E.XN.t9 VSS 1.48871f
C387 XFE_E.XN.n36 VSS 2.31351f
C388 XFE_E.XN.n37 VSS 2.80884f
C389 XFE_E.XN.t13 VSS 0.30289f
C390 XFE_E.XN.t30 VSS 0.30031f
C391 XFE_E.XN.n38 VSS 1.07282f
C392 XFE_E.XN.t29 VSS 0.30031f
C393 XFE_E.XN.t15 VSS 0.30031f
C394 XFE_E.XN.n39 VSS 1.06449f
C395 XFE_E.XN.n40 VSS 0.53944f
C396 XFE_E.XN.t14 VSS 0.30031f
C397 XFE_E.XN.t17 VSS 0.30031f
C398 XFE_E.XN.n41 VSS 1.06449f
C399 XFE_E.XN.t16 VSS 0.30031f
C400 XFE_E.XN.t18 VSS 0.30288f
C401 XFE_E.XN.n42 VSS 1.07282f
C402 XFE_E.XN.n43 VSS 1.44722f
C403 XFE_E.XN.n44 VSS 1.69004f
C404 XFE_E.XN.n45 VSS 1.44329f
C405 XFE_E.XN.n46 VSS 3.21788f
C406 XFE_E.XN.n47 VSS 0.24424f
C407 XFE_E.XN.n48 VSS 0.25216f
C408 XFE_E.XN.n49 VSS 0.25216f
C409 XFE_E.XN.n50 VSS 0.18011f
C410 XFE_E.XN.n51 VSS 0.11679f
C411 XFE_E.XN.n52 VSS 0.11679f
C412 XFE_E.XN.n53 VSS 0.33994f
C413 XFE_E.XN.n54 VSS 0.25242f
C414 XFE_E.XN.n55 VSS 0.25242f
C415 XFE_E.XN.n56 VSS 0.25242f
C416 XFE_E.XN.n57 VSS 0.25242f
C417 XFE_E.XN.n58 VSS 0.25242f
C418 XFE_E.XN.n59 VSS 0.49868f
C419 XFE_E.XN.n60 VSS 0.16803f
C420 XFE_E.XN.n61 VSS 0.18011f
C421 XFE_E.XN.n62 VSS 0.18011f
C422 XFE_E.XN.n63 VSS 0.18011f
C423 XFE_E.XN.n64 VSS 0.18011f
C424 XFE_E.XN.n65 VSS 0.18011f
C425 XFE_E.XN.n66 VSS 0.11679f
C426 XFE_E.XN.n67 VSS 0.11679f
C427 XFE_E.XN.n68 VSS 0.11653f
C428 XFE_E.XN.n69 VSS 0.18011f
C429 XFE_E.XN.n70 VSS 0.18011f
C430 XFE_E.XN.n71 VSS 0.49868f
C431 XFE_E.XN.n72 VSS 0.16803f
C432 XFE_E.XN.n73 VSS 0.33968f
C433 XFE_E.XN.n74 VSS 0.18011f
C434 XFE_E.XN.n75 VSS 0.18011f
C435 XFE_E.XN.n76 VSS 0.29791f
C436 XFE_E.XN.n77 VSS 1.89723f
C437 XFE_E.XN.n78 VSS 1.10618f
C438 XFE_O.XN.t9 VSS 1.40085f
C439 XFE_O.XN.t0 VSS 1.40913f
C440 XFE_O.XN.t2 VSS 0.30031f
C441 XFE_O.XN.t1 VSS 0.30031f
C442 XFE_O.XN.n0 VSS 1.06449f
C443 XFE_O.XN.n1 VSS 0.58512f
C444 XFE_O.XN.t4 VSS 0.30031f
C445 XFE_O.XN.t3 VSS 0.30031f
C446 XFE_O.XN.n2 VSS 1.06449f
C447 XFE_O.XN.n3 VSS 0.30545f
C448 XFE_O.XN.t6 VSS 0.30031f
C449 XFE_O.XN.t5 VSS 0.30031f
C450 XFE_O.XN.n4 VSS 1.06449f
C451 XFE_O.XN.n5 VSS 0.30545f
C452 XFE_O.XN.t8 VSS 0.30031f
C453 XFE_O.XN.t7 VSS 0.30031f
C454 XFE_O.XN.n6 VSS 1.06449f
C455 XFE_O.XN.n7 VSS 0.24533f
C456 XFE_O.XN.n8 VSS 1.66511f
C457 XFE_O.XN.n9 VSS 0.32954f
C458 XFE_O.XN.n10 VSS 0.16803f
C459 XFE_O.XN.n11 VSS 0.18011f
C460 XFE_O.XN.n12 VSS 0.18011f
C461 XFE_O.XN.n13 VSS 0.17033f
C462 XFE_O.XN.n14 VSS 0.3775f
C463 XFE_O.XN.n15 VSS 2.16471f
C464 XFE_O.XN.n16 VSS 0.9973f
C465 XFE_O.XN.n17 VSS 1.42665f
C466 XFE_O.XN.t29 VSS 1.43937f
C467 XFE_O.XN.t28 VSS 0.33222f
C468 XFE_O.XN.t27 VSS 0.33222f
C469 XFE_O.XN.n18 VSS 1.05664f
C470 XFE_O.XN.n19 VSS 0.59551f
C471 XFE_O.XN.t26 VSS 0.33222f
C472 XFE_O.XN.t25 VSS 0.33222f
C473 XFE_O.XN.n20 VSS 1.05664f
C474 XFE_O.XN.n21 VSS 0.31329f
C475 XFE_O.XN.t24 VSS 0.33222f
C476 XFE_O.XN.t23 VSS 0.33222f
C477 XFE_O.XN.n22 VSS 1.05664f
C478 XFE_O.XN.n23 VSS 0.25318f
C479 XFE_O.XN.t18 VSS 1.43937f
C480 XFE_O.XN.t20 VSS 0.33222f
C481 XFE_O.XN.t19 VSS 0.33222f
C482 XFE_O.XN.n24 VSS 1.05664f
C483 XFE_O.XN.n25 VSS 0.59551f
C484 XFE_O.XN.t22 VSS 0.33222f
C485 XFE_O.XN.t21 VSS 0.33222f
C486 XFE_O.XN.n26 VSS 1.05664f
C487 XFE_O.XN.n27 VSS 0.25318f
C488 XFE_O.XN.n28 VSS 0.85518f
C489 XFE_O.XN.n29 VSS 1.72642f
C490 XFE_O.XN.t31 VSS 1.48871f
C491 XFE_O.XN.t30 VSS 1.47912f
C492 XFE_O.XN.n30 VSS 2.31351f
C493 XFE_O.XN.n31 VSS 2.80884f
C494 XFE_O.XN.t17 VSS 0.30288f
C495 XFE_O.XN.t16 VSS 0.30031f
C496 XFE_O.XN.n32 VSS 1.07282f
C497 XFE_O.XN.t15 VSS 0.30031f
C498 XFE_O.XN.t14 VSS 0.30031f
C499 XFE_O.XN.n33 VSS 1.06449f
C500 XFE_O.XN.t11 VSS 0.30031f
C501 XFE_O.XN.t10 VSS 0.30289f
C502 XFE_O.XN.n34 VSS 1.07282f
C503 XFE_O.XN.t13 VSS 0.30031f
C504 XFE_O.XN.t12 VSS 0.30031f
C505 XFE_O.XN.n35 VSS 1.06449f
C506 XFE_O.XN.n36 VSS 0.53944f
C507 XFE_O.XN.n37 VSS 1.44722f
C508 XFE_O.XN.n38 VSS 1.69004f
C509 XFE_O.XN.n39 VSS 1.44329f
C510 XFE_O.XN.n40 VSS 3.21788f
C511 XFE_O.XN.n41 VSS 0.24424f
C512 XFE_O.XN.n42 VSS 0.25216f
C513 XFE_O.XN.n43 VSS 0.25216f
C514 XFE_O.XN.n44 VSS 0.18011f
C515 XFE_O.XN.n45 VSS 0.49868f
C516 XFE_O.XN.n46 VSS 0.16803f
C517 XFE_O.XN.n47 VSS 0.33968f
C518 XFE_O.XN.n48 VSS 0.18011f
C519 XFE_O.XN.n49 VSS 0.11653f
C520 XFE_O.XN.n50 VSS 0.11679f
C521 XFE_O.XN.n51 VSS 0.11679f
C522 XFE_O.XN.n52 VSS 0.11679f
C523 XFE_O.XN.n53 VSS 0.11679f
C524 XFE_O.XN.n54 VSS 0.18011f
C525 XFE_O.XN.n55 VSS 0.25242f
C526 XFE_O.XN.n56 VSS 0.25242f
C527 XFE_O.XN.n57 VSS 0.25242f
C528 XFE_O.XN.n58 VSS 0.25242f
C529 XFE_O.XN.n59 VSS 0.25242f
C530 XFE_O.XN.n60 VSS 0.49868f
C531 XFE_O.XN.n61 VSS 0.16803f
C532 XFE_O.XN.n62 VSS 0.33994f
C533 XFE_O.XN.n63 VSS 0.18011f
C534 XFE_O.XN.n64 VSS 0.18011f
C535 XFE_O.XN.n65 VSS 0.18011f
C536 XFE_O.XN.n66 VSS 0.18011f
C537 XFE_O.XN.n67 VSS 0.18011f
C538 XFE_O.XN.n68 VSS 0.18011f
C539 XFE_O.XN.n69 VSS 0.18011f
C540 XFE_O.XN.n70 VSS 0.29791f
C541 XFE_O.XN.n71 VSS 1.89723f
C542 XFE_O.XN.n72 VSS 1.11528f
C543 XFE_O.XN.n73 VSS 0.17033f
C544 XFE_O.XN.n74 VSS 0.16803f
C545 XFE_O.XN.n75 VSS 0.18011f
C546 XFE_O.XN.n76 VSS 0.18011f
C547 XFE_O.XN.n77 VSS 0.32954f
C548 XFE_O.XN.n78 VSS 1.2398f
C549 XFE_O.XN.n79 VSS 1.90891f
C550 XFE_O.XP.n0 VSS 0.33737f
C551 XFE_O.XP.n1 VSS 0.16675f
C552 XFE_O.XP.n2 VSS 0.17874f
C553 XFE_O.XP.n3 VSS 0.17874f
C554 XFE_O.XP.n4 VSS 0.16893f
C555 XFE_O.XP.n5 VSS 1.42089f
C556 XFE_O.XP.n6 VSS 0.24239f
C557 XFE_O.XP.n7 VSS 0.25025f
C558 XFE_O.XP.n8 VSS 0.25025f
C559 XFE_O.XP.n9 VSS 0.17874f
C560 XFE_O.XP.n10 VSS 0.4949f
C561 XFE_O.XP.n11 VSS 0.16675f
C562 XFE_O.XP.n12 VSS 0.3371f
C563 XFE_O.XP.n13 VSS 0.17874f
C564 XFE_O.XP.n14 VSS 0.11565f
C565 XFE_O.XP.n15 VSS 0.11591f
C566 XFE_O.XP.n16 VSS 0.11591f
C567 XFE_O.XP.n17 VSS 0.11591f
C568 XFE_O.XP.n18 VSS 0.11591f
C569 XFE_O.XP.n19 VSS 0.17874f
C570 XFE_O.XP.n20 VSS 0.25051f
C571 XFE_O.XP.n21 VSS 0.25051f
C572 XFE_O.XP.n22 VSS 0.25051f
C573 XFE_O.XP.n23 VSS 0.25051f
C574 XFE_O.XP.n24 VSS 0.25051f
C575 XFE_O.XP.n25 VSS 0.4949f
C576 XFE_O.XP.n26 VSS 0.16675f
C577 XFE_O.XP.n27 VSS 0.33737f
C578 XFE_O.XP.n28 VSS 0.17874f
C579 XFE_O.XP.n29 VSS 0.17874f
C580 XFE_O.XP.n30 VSS 0.17874f
C581 XFE_O.XP.n31 VSS 0.17874f
C582 XFE_O.XP.n32 VSS 0.17874f
C583 XFE_O.XP.n33 VSS 0.17874f
C584 XFE_O.XP.n34 VSS 0.17874f
C585 XFE_O.XP.n35 VSS 0.29566f
C586 XFE_O.XP.n36 VSS 1.795f
C587 XFE_O.XP.n37 VSS 3.10172f
C588 XFE_O.XP.n38 VSS 1.47542f
C589 XFE_O.XP.n39 VSS 3.45737f
C590 XFE_O.XP.t18 VSS 1.39919f
C591 XFE_O.XP.t21 VSS 0.29876f
C592 XFE_O.XP.t20 VSS 0.29876f
C593 XFE_O.XP.n40 VSS 1.05643f
C594 XFE_O.XP.n41 VSS 0.58069f
C595 XFE_O.XP.t16 VSS 0.29876f
C596 XFE_O.XP.t14 VSS 0.29876f
C597 XFE_O.XP.n42 VSS 1.05643f
C598 XFE_O.XP.n43 VSS 0.24348f
C599 XFE_O.XP.t17 VSS 1.3992f
C600 XFE_O.XP.t19 VSS 0.29876f
C601 XFE_O.XP.t15 VSS 0.29876f
C602 XFE_O.XP.n44 VSS 1.05643f
C603 XFE_O.XP.n45 VSS 0.52103f
C604 XFE_O.XP.n46 VSS 1.37228f
C605 XFE_O.XP.n47 VSS 2.05638f
C606 XFE_O.XP.t2 VSS 1.47329f
C607 XFE_O.XP.t13 VSS 1.47571f
C608 XFE_O.XP.n48 VSS 2.36091f
C609 XFE_O.XP.n49 VSS 2.92298f
C610 XFE_O.XP.t7 VSS 1.43044f
C611 XFE_O.XP.t9 VSS 0.33163f
C612 XFE_O.XP.t10 VSS 0.33163f
C613 XFE_O.XP.n50 VSS 1.04864f
C614 XFE_O.XP.n51 VSS 0.591f
C615 XFE_O.XP.t0 VSS 0.33163f
C616 XFE_O.XP.t1 VSS 0.33163f
C617 XFE_O.XP.n52 VSS 1.04864f
C618 XFE_O.XP.n53 VSS 0.31092f
C619 XFE_O.XP.t11 VSS 0.33163f
C620 XFE_O.XP.t12 VSS 0.33163f
C621 XFE_O.XP.n54 VSS 1.04864f
C622 XFE_O.XP.n55 VSS 0.25126f
C623 XFE_O.XP.t8 VSS 1.43044f
C624 XFE_O.XP.t5 VSS 0.33163f
C625 XFE_O.XP.t6 VSS 0.33163f
C626 XFE_O.XP.n56 VSS 1.04864f
C627 XFE_O.XP.n57 VSS 0.591f
C628 XFE_O.XP.t3 VSS 0.33163f
C629 XFE_O.XP.t4 VSS 0.33163f
C630 XFE_O.XP.n58 VSS 1.04864f
C631 XFE_O.XP.n59 VSS 0.25126f
C632 XFE_O.XP.n60 VSS 0.78552f
C633 XFE_O.XP.n61 VSS 1.62307f
C634 XFE_O.XP.n62 VSS 0.95385f
C635 XFE_O.XP.n63 VSS 1.25315f
C636 XFE_O.XP.n64 VSS 0.16904f
C637 XFE_O.XP.n65 VSS 0.16675f
C638 XFE_O.XP.n66 VSS 0.17874f
C639 XFE_O.XP.n67 VSS 0.17874f
C640 XFE_O.XP.n68 VSS 0.32704f
C641 XFE_O.XP.n69 VSS 0.42062f
C642 XFE_O.XP.n70 VSS 0.87173f
C643 XFE_O.XP.t31 VSS 1.3992f
C644 XFE_O.XP.t30 VSS 0.29876f
C645 XFE_O.XP.t29 VSS 0.29876f
C646 XFE_O.XP.n71 VSS 1.05643f
C647 XFE_O.XP.n72 VSS 0.58069f
C648 XFE_O.XP.t28 VSS 0.29876f
C649 XFE_O.XP.t27 VSS 0.29876f
C650 XFE_O.XP.n73 VSS 1.05643f
C651 XFE_O.XP.n74 VSS 0.30313f
C652 XFE_O.XP.t26 VSS 0.29876f
C653 XFE_O.XP.t25 VSS 0.29876f
C654 XFE_O.XP.n75 VSS 1.05643f
C655 XFE_O.XP.n76 VSS 0.30313f
C656 XFE_O.XP.t24 VSS 0.29876f
C657 XFE_O.XP.t23 VSS 0.29876f
C658 XFE_O.XP.n77 VSS 1.05643f
C659 XFE_O.XP.n78 VSS 0.28822f
C660 XFE_O.XP.t22 VSS 1.38791f
C661 XFE_O.XP.n79 VSS 1.55413f
C662 XFE_O.XP.n80 VSS 1.56891f
C663 XFE_E.HB.n0 VSS 0.2398f
C664 XFE_E.HB.n1 VSS 0.11853f
C665 XFE_E.HB.n2 VSS 0.12705f
C666 XFE_E.HB.n3 VSS 0.12705f
C667 XFE_E.HB.n4 VSS 0.12008f
C668 XFE_E.HB.n5 VSS 0.46053f
C669 XFE_E.HB.n6 VSS 0.11853f
C670 XFE_E.HB.n7 VSS 0.12705f
C671 XFE_E.HB.n8 VSS 0.12008f
C672 XFE_E.HB.n9 VSS 0.67097f
C673 XFE_E.HB.n10 VSS 0.12015f
C674 XFE_E.HB.n11 VSS 0.11853f
C675 XFE_E.HB.n12 VSS 0.12705f
C676 XFE_E.HB.n13 VSS 0.12705f
C677 XFE_E.HB.n14 VSS 0.23246f
C678 XFE_E.HB.n15 VSS 0.2663f
C679 XFE_E.HB.n16 VSS 1.55603f
C680 XFE_E.HB.t10 VSS 0.995f
C681 XFE_E.HB.t9 VSS 0.21453f
C682 XFE_E.HB.t8 VSS 0.21453f
C683 XFE_E.HB.n17 VSS 0.74539f
C684 XFE_E.HB.n18 VSS 0.37768f
C685 XFE_E.HB.t3 VSS 0.99499f
C686 XFE_E.HB.t5 VSS 0.21453f
C687 XFE_E.HB.t4 VSS 0.21453f
C688 XFE_E.HB.n19 VSS 0.74539f
C689 XFE_E.HB.n20 VSS 0.42009f
C690 XFE_E.HB.t7 VSS 0.21453f
C691 XFE_E.HB.t6 VSS 0.21453f
C692 XFE_E.HB.n21 VSS 0.74539f
C693 XFE_E.HB.n22 VSS 0.1786f
C694 XFE_E.HB.n23 VSS 0.17978f
C695 XFE_E.HB.n24 VSS 0.85854f
C696 XFE_E.HB.t16 VSS 1.04006f
C697 XFE_E.HB.t13 VSS 1.04186f
C698 XFE_E.HB.t15 VSS 0.26148f
C699 XFE_E.HB.t14 VSS 0.26148f
C700 XFE_E.HB.n25 VSS 0.75092f
C701 XFE_E.HB.n26 VSS 0.37035f
C702 XFE_E.HB.n27 VSS 0.88409f
C703 XFE_E.HB.n28 VSS 0.92912f
C704 XFE_E.HB.t12 VSS 1.31404f
C705 XFE_E.HB.n29 VSS 0.72746f
C706 XFE_E.HB.t11 VSS 1.10226f
C707 XFE_E.HB.t0 VSS 0.31856f
C708 XFE_E.HB.t1 VSS 0.31856f
C709 XFE_E.HB.n30 VSS 0.75092f
C710 XFE_E.HB.n31 VSS 0.33855f
C711 XFE_E.HB.t2 VSS 1.09781f
C712 XFE_E.HB.n32 VSS 1.68299f
C713 XFE_E.HB.n33 VSS 3.98342f
C714 XFE_E.HB.n34 VSS 3.12293f
C715 XFE_E.H.n0 VSS 0.11342f
C716 XFE_E.H.n1 VSS 0.11189f
C717 XFE_E.H.n2 VSS 0.11993f
C718 XFE_E.H.n3 VSS 0.11993f
C719 XFE_E.H.n4 VSS 0.21944f
C720 XFE_E.H.n5 VSS 0.22162f
C721 XFE_E.H.n6 VSS 0.21944f
C722 XFE_E.H.n7 VSS 0.11189f
C723 XFE_E.H.n8 VSS 0.11993f
C724 XFE_E.H.n9 VSS 0.11993f
C725 XFE_E.H.n10 VSS 0.11342f
C726 XFE_E.H.n11 VSS 0.44107f
C727 XFE_E.H.n12 VSS 3.43313f
C728 XFE_E.H.t6 VSS 1.04796f
C729 XFE_E.H.t5 VSS 1.04841f
C730 XFE_E.H.t7 VSS 0.31176f
C731 XFE_E.H.t8 VSS 0.31176f
C732 XFE_E.H.n13 VSS 0.70885f
C733 XFE_E.H.n14 VSS 0.3496f
C734 XFE_E.H.n15 VSS 1.60381f
C735 XFE_E.H.n16 VSS 3.91167f
C736 XFE_E.H.t3 VSS 1.22975f
C737 XFE_E.H.n17 VSS 0.73537f
C738 XFE_E.H.t4 VSS 0.99312f
C739 XFE_E.H.t2 VSS 0.99928f
C740 XFE_E.H.t0 VSS 0.26026f
C741 XFE_E.H.t1 VSS 0.26026f
C742 XFE_E.H.n18 VSS 0.70885f
C743 XFE_E.H.n19 VSS 0.3496f
C744 XFE_E.H.n20 VSS 0.87696f
C745 XFE_E.H.n21 VSS 0.88918f
C746 XFE_E.H.t16 VSS 0.94461f
C747 XFE_E.H.t15 VSS 0.20773f
C748 XFE_E.H.t14 VSS 0.20773f
C749 XFE_E.H.n22 VSS 0.70363f
C750 XFE_E.H.n23 VSS 0.35652f
C751 XFE_E.H.t9 VSS 0.94461f
C752 XFE_E.H.t11 VSS 0.20773f
C753 XFE_E.H.t10 VSS 0.20773f
C754 XFE_E.H.n24 VSS 0.70363f
C755 XFE_E.H.n25 VSS 0.39655f
C756 XFE_E.H.t13 VSS 0.20773f
C757 XFE_E.H.t12 VSS 0.20773f
C758 XFE_E.H.n26 VSS 0.70363f
C759 XFE_E.H.n27 VSS 0.1686f
C760 XFE_E.H.n28 VSS 0.2121f
C761 XFE_E.H.n29 VSS 0.7741f
C762 XFE_E.H.n30 VSS 0.11189f
C763 XFE_E.H.n31 VSS 0.11993f
C764 XFE_E.H.n32 VSS 0.11335f
C765 XFE_E.H.n33 VSS 0.64427f
C766 XFE_E.H.n34 VSS 1.07962f
C767 XFE_O.H.n0 VSS 0.11342f
C768 XFE_O.H.n1 VSS 0.11189f
C769 XFE_O.H.n2 VSS 0.11993f
C770 XFE_O.H.n3 VSS 0.11993f
C771 XFE_O.H.n4 VSS 0.21944f
C772 XFE_O.H.n5 VSS 0.44107f
C773 XFE_O.H.n6 VSS 3.43312f
C774 XFE_O.H.t9 VSS 1.04841f
C775 XFE_O.H.t10 VSS 0.31176f
C776 XFE_O.H.t11 VSS 0.31176f
C777 XFE_O.H.n7 VSS 0.70885f
C778 XFE_O.H.n8 VSS 0.3496f
C779 XFE_O.H.t0 VSS 1.04796f
C780 XFE_O.H.n9 VSS 1.60381f
C781 XFE_O.H.n10 VSS 3.91167f
C782 XFE_O.H.t12 VSS 1.22975f
C783 XFE_O.H.n11 VSS 0.73537f
C784 XFE_O.H.t16 VSS 0.99928f
C785 XFE_O.H.t15 VSS 0.26026f
C786 XFE_O.H.t14 VSS 0.26026f
C787 XFE_O.H.n12 VSS 0.70885f
C788 XFE_O.H.n13 VSS 0.3496f
C789 XFE_O.H.t13 VSS 0.99312f
C790 XFE_O.H.n14 VSS 0.87696f
C791 XFE_O.H.n15 VSS 0.88918f
C792 XFE_O.H.t8 VSS 0.94461f
C793 XFE_O.H.t7 VSS 0.20773f
C794 XFE_O.H.t6 VSS 0.20773f
C795 XFE_O.H.n16 VSS 0.70362f
C796 XFE_O.H.n17 VSS 0.39655f
C797 XFE_O.H.t5 VSS 0.20773f
C798 XFE_O.H.t4 VSS 0.20773f
C799 XFE_O.H.n18 VSS 0.70362f
C800 XFE_O.H.n19 VSS 0.1686f
C801 XFE_O.H.t1 VSS 0.94461f
C802 XFE_O.H.t3 VSS 0.20773f
C803 XFE_O.H.t2 VSS 0.20773f
C804 XFE_O.H.n20 VSS 0.70362f
C805 XFE_O.H.n21 VSS 0.35652f
C806 XFE_O.H.n22 VSS 0.2121f
C807 XFE_O.H.n23 VSS 0.7741f
C808 XFE_O.H.n24 VSS 0.11189f
C809 XFE_O.H.n25 VSS 0.11993f
C810 XFE_O.H.n26 VSS 0.11335f
C811 XFE_O.H.n27 VSS 0.64427f
C812 XFE_O.H.n28 VSS 1.08568f
C813 XFE_O.H.n29 VSS 0.21944f
C814 XFE_O.H.n30 VSS 0.11189f
C815 XFE_O.H.n31 VSS 0.11993f
C816 XFE_O.H.n32 VSS 0.11993f
C817 XFE_O.H.n33 VSS 0.11342f
C818 XFE_O.H.n34 VSS 0.22097f
C819 XFE_O.H.n35 VSS 0.30698f
C820 XFE_O.HB.n0 VSS 0.11853f
C821 XFE_O.HB.n1 VSS 0.12705f
C822 XFE_O.HB.n2 VSS 0.12008f
C823 XFE_O.HB.n3 VSS 0.67097f
C824 XFE_O.HB.n4 VSS 0.23246f
C825 XFE_O.HB.n5 VSS 0.11853f
C826 XFE_O.HB.n6 VSS 0.12705f
C827 XFE_O.HB.n7 VSS 0.12705f
C828 XFE_O.HB.n8 VSS 0.12015f
C829 XFE_O.HB.n9 VSS 0.2663f
C830 XFE_O.HB.n10 VSS 1.55603f
C831 XFE_O.HB.t12 VSS 0.99499f
C832 XFE_O.HB.t11 VSS 0.21453f
C833 XFE_O.HB.t10 VSS 0.21453f
C834 XFE_O.HB.n11 VSS 0.74539f
C835 XFE_O.HB.n12 VSS 0.42009f
C836 XFE_O.HB.t9 VSS 0.21453f
C837 XFE_O.HB.t8 VSS 0.21453f
C838 XFE_O.HB.n13 VSS 0.74539f
C839 XFE_O.HB.n14 VSS 0.1786f
C840 XFE_O.HB.t5 VSS 0.995f
C841 XFE_O.HB.t7 VSS 0.21453f
C842 XFE_O.HB.t6 VSS 0.21453f
C843 XFE_O.HB.n15 VSS 0.74539f
C844 XFE_O.HB.n16 VSS 0.37768f
C845 XFE_O.HB.n17 VSS 0.17978f
C846 XFE_O.HB.n18 VSS 0.85854f
C847 XFE_O.HB.t3 VSS 1.04186f
C848 XFE_O.HB.t4 VSS 0.26148f
C849 XFE_O.HB.t0 VSS 0.26148f
C850 XFE_O.HB.n19 VSS 0.75093f
C851 XFE_O.HB.n20 VSS 0.37035f
C852 XFE_O.HB.t1 VSS 1.04007f
C853 XFE_O.HB.n21 VSS 0.88409f
C854 XFE_O.HB.n22 VSS 0.92912f
C855 XFE_O.HB.t2 VSS 1.31404f
C856 XFE_O.HB.n23 VSS 0.72746f
C857 XFE_O.HB.t15 VSS 1.09781f
C858 XFE_O.HB.t14 VSS 1.10226f
C859 XFE_O.HB.t16 VSS 0.31856f
C860 XFE_O.HB.t13 VSS 0.31856f
C861 XFE_O.HB.n24 VSS 0.75093f
C862 XFE_O.HB.n25 VSS 0.33855f
C863 XFE_O.HB.n26 VSS 1.68299f
C864 XFE_O.HB.n27 VSS 3.98342f
C865 XFE_O.HB.n28 VSS 3.12935f
C866 XFE_O.HB.n29 VSS 0.2398f
C867 XFE_O.HB.n30 VSS 0.11853f
C868 XFE_O.HB.n31 VSS 0.12705f
C869 XFE_O.HB.n32 VSS 0.12705f
C870 XFE_O.HB.n33 VSS 0.12008f
C871 XFE_O.HB.n34 VSS 0.4592f
C872 XFE_O.HB.n35 VSS 0.70771f
C873 XFE_E.NIN.t19 VSS 1.60137f
C874 XFE_E.NIN.t18 VSS 0.29711f
C875 XFE_E.NIN.t17 VSS 0.29711f
C876 XFE_E.NIN.n0 VSS 1.24724f
C877 XFE_E.NIN.n1 VSS 0.63197f
C878 XFE_E.NIN.t12 VSS 1.60138f
C879 XFE_E.NIN.t14 VSS 0.29711f
C880 XFE_E.NIN.t13 VSS 0.29711f
C881 XFE_E.NIN.n2 VSS 1.24724f
C882 XFE_E.NIN.n3 VSS 0.70293f
C883 XFE_E.NIN.t16 VSS 0.29711f
C884 XFE_E.NIN.t15 VSS 0.29711f
C885 XFE_E.NIN.n4 VSS 1.24724f
C886 XFE_E.NIN.n5 VSS 0.29885f
C887 XFE_E.NIN.n6 VSS 0.9909f
C888 XFE_E.NIN.t8 VSS 0.37276f
C889 XFE_E.NIN.t10 VSS 0.36932f
C890 XFE_E.NIN.n7 VSS 1.25728f
C891 XFE_E.NIN.t11 VSS 0.36932f
C892 XFE_E.NIN.t6 VSS 0.36932f
C893 XFE_E.NIN.n8 VSS 1.24724f
C894 XFE_E.NIN.n9 VSS 0.65507f
C895 XFE_E.NIN.t7 VSS 0.36932f
C896 XFE_E.NIN.t0 VSS 0.36932f
C897 XFE_E.NIN.n10 VSS 1.24724f
C898 XFE_E.NIN.n11 VSS 0.36981f
C899 XFE_E.NIN.t1 VSS 0.36932f
C900 XFE_E.NIN.t2 VSS 0.36932f
C901 XFE_E.NIN.n12 VSS 1.24724f
C902 XFE_E.NIN.t5 VSS 0.36932f
C903 XFE_E.NIN.t9 VSS 0.37276f
C904 XFE_E.NIN.n13 VSS 1.25728f
C905 XFE_E.NIN.t3 VSS 0.36932f
C906 XFE_E.NIN.t4 VSS 0.36932f
C907 XFE_E.NIN.n14 VSS 1.24724f
C908 XFE_E.NIN.n15 VSS 0.65507f
C909 XFE_E.NIN.n16 VSS 1.00904f
C910 XFE_E.NIN.t23 VSS 1.67404f
C911 XFE_E.NIN.t20 VSS 1.67828f
C912 XFE_E.NIN.t22 VSS 0.37249f
C913 XFE_E.NIN.t21 VSS 0.37249f
C914 XFE_E.NIN.n17 VSS 1.25651f
C915 XFE_E.NIN.n18 VSS 0.61971f
C916 XFE_E.NIN.n19 VSS 3.4549f
C917 XFE_E.NIN.n20 VSS 4.90308f
C918 XFE_E.NIP.t2 VSS 0.37035f
C919 XFE_E.NIP.t3 VSS 0.36688f
C920 XFE_E.NIP.n0 VSS 1.23967f
C921 XFE_E.NIP.t14 VSS 0.36688f
C922 XFE_E.NIP.t15 VSS 0.36688f
C923 XFE_E.NIP.n1 VSS 1.22977f
C924 XFE_E.NIP.n2 VSS 0.6459f
C925 XFE_E.NIP.t18 VSS 0.36688f
C926 XFE_E.NIP.t19 VSS 0.36688f
C927 XFE_E.NIP.n3 VSS 1.22977f
C928 XFE_E.NIP.n4 VSS 0.36463f
C929 XFE_E.NIP.t16 VSS 0.36688f
C930 XFE_E.NIP.t17 VSS 0.36688f
C931 XFE_E.NIP.n5 VSS 1.22977f
C932 XFE_E.NIP.t0 VSS 0.36688f
C933 XFE_E.NIP.t1 VSS 0.37035f
C934 XFE_E.NIP.n6 VSS 1.23967f
C935 XFE_E.NIP.t4 VSS 0.36688f
C936 XFE_E.NIP.t5 VSS 0.36688f
C937 XFE_E.NIP.n7 VSS 1.22977f
C938 XFE_E.NIP.n8 VSS 0.6459f
C939 XFE_E.NIP.n9 VSS 0.93638f
C940 XFE_E.NIP.t13 VSS 1.57991f
C941 XFE_E.NIP.t12 VSS 0.2939f
C942 XFE_E.NIP.t11 VSS 0.2939f
C943 XFE_E.NIP.n10 VSS 1.22977f
C944 XFE_E.NIP.n11 VSS 0.62312f
C945 XFE_E.NIP.t6 VSS 1.57991f
C946 XFE_E.NIP.t8 VSS 0.2939f
C947 XFE_E.NIP.t7 VSS 0.2939f
C948 XFE_E.NIP.n12 VSS 1.22977f
C949 XFE_E.NIP.n13 VSS 0.69308f
C950 XFE_E.NIP.t10 VSS 0.2939f
C951 XFE_E.NIP.t9 VSS 0.2939f
C952 XFE_E.NIP.n14 VSS 1.22977f
C953 XFE_E.NIP.n15 VSS 0.29467f
C954 XFE_E.NIP.n16 VSS 1.25236f
C955 XFE_E.NIP.t23 VSS 1.65244f
C956 XFE_E.NIP.t20 VSS 1.65659f
C957 XFE_E.NIP.t22 VSS 0.36909f
C958 XFE_E.NIP.t21 VSS 0.36909f
C959 XFE_E.NIP.n17 VSS 1.23891f
C960 XFE_E.NIP.n18 VSS 0.61102f
C961 XFE_E.NIP.n19 VSS 3.48061f
C962 XFE_E.NIP.n20 VSS 5.15681f
C963 XFE_O.NIP.t23 VSS 1.57972f
C964 XFE_O.NIP.t22 VSS 0.29371f
C965 XFE_O.NIP.t21 VSS 0.29371f
C966 XFE_O.NIP.n0 VSS 1.22977f
C967 XFE_O.NIP.n1 VSS 0.69308f
C968 XFE_O.NIP.t20 VSS 0.29371f
C969 XFE_O.NIP.t19 VSS 0.29371f
C970 XFE_O.NIP.n2 VSS 1.22977f
C971 XFE_O.NIP.n3 VSS 0.29467f
C972 XFE_O.NIP.t16 VSS 1.57973f
C973 XFE_O.NIP.t18 VSS 0.29371f
C974 XFE_O.NIP.t17 VSS 0.29371f
C975 XFE_O.NIP.n4 VSS 1.22977f
C976 XFE_O.NIP.n5 VSS 0.62312f
C977 XFE_O.NIP.n6 VSS 1.25236f
C978 XFE_O.NIP.t15 VSS 1.65659f
C979 XFE_O.NIP.t14 VSS 0.36909f
C980 XFE_O.NIP.t13 VSS 0.36909f
C981 XFE_O.NIP.n7 VSS 1.23891f
C982 XFE_O.NIP.n8 VSS 0.61102f
C983 XFE_O.NIP.t12 VSS 1.65244f
C984 XFE_O.NIP.n9 VSS 3.48061f
C985 XFE_O.NIP.n10 VSS 5.1674f
C986 XFE_O.NIP.t6 VSS 0.37035f
C987 XFE_O.NIP.t8 VSS 0.36688f
C988 XFE_O.NIP.n11 VSS 1.23967f
C989 XFE_O.NIP.t9 VSS 0.36688f
C990 XFE_O.NIP.t0 VSS 0.36688f
C991 XFE_O.NIP.n12 VSS 1.22977f
C992 XFE_O.NIP.n13 VSS 0.6459f
C993 XFE_O.NIP.t1 VSS 0.36688f
C994 XFE_O.NIP.t10 VSS 0.36688f
C995 XFE_O.NIP.n14 VSS 1.22977f
C996 XFE_O.NIP.t5 VSS 0.36688f
C997 XFE_O.NIP.t7 VSS 0.37035f
C998 XFE_O.NIP.n15 VSS 1.23967f
C999 XFE_O.NIP.t3 VSS 0.36688f
C1000 XFE_O.NIP.t4 VSS 0.36688f
C1001 XFE_O.NIP.n16 VSS 1.22977f
C1002 XFE_O.NIP.n17 VSS 0.6459f
C1003 XFE_O.NIP.t11 VSS 0.36688f
C1004 XFE_O.NIP.t2 VSS 0.36688f
C1005 XFE_O.NIP.n18 VSS 1.22977f
C1006 XFE_O.NIP.n19 VSS 0.36463f
C1007 XFE_O.NIP.n20 VSS 0.93417f
C1008 XFE_O.NIP.n21 VSS 0.86596f
C1009 XFE_O.NIN.t2 VSS 0.37276f
C1010 XFE_O.NIN.t3 VSS 0.36932f
C1011 XFE_O.NIN.n0 VSS 1.25728f
C1012 XFE_O.NIN.t4 VSS 0.36932f
C1013 XFE_O.NIN.t5 VSS 0.36932f
C1014 XFE_O.NIN.n1 VSS 1.24724f
C1015 XFE_O.NIN.n2 VSS 0.65507f
C1016 XFE_O.NIN.t6 VSS 0.36932f
C1017 XFE_O.NIN.t7 VSS 0.36932f
C1018 XFE_O.NIN.n3 VSS 1.24724f
C1019 XFE_O.NIN.t22 VSS 0.36932f
C1020 XFE_O.NIN.t23 VSS 0.37276f
C1021 XFE_O.NIN.n4 VSS 1.25728f
C1022 XFE_O.NIN.t16 VSS 0.36932f
C1023 XFE_O.NIN.t17 VSS 0.36932f
C1024 XFE_O.NIN.n5 VSS 1.24724f
C1025 XFE_O.NIN.n6 VSS 0.65507f
C1026 XFE_O.NIN.t0 VSS 0.36932f
C1027 XFE_O.NIN.t1 VSS 0.36932f
C1028 XFE_O.NIN.n7 VSS 1.24724f
C1029 XFE_O.NIN.n8 VSS 0.36981f
C1030 XFE_O.NIN.n9 VSS 1.00904f
C1031 XFE_O.NIN.t21 VSS 1.67828f
C1032 XFE_O.NIN.t20 VSS 0.37249f
C1033 XFE_O.NIN.t19 VSS 0.37249f
C1034 XFE_O.NIN.n10 VSS 1.25651f
C1035 XFE_O.NIN.n11 VSS 0.61971f
C1036 XFE_O.NIN.t18 VSS 1.67404f
C1037 XFE_O.NIN.n12 VSS 3.4549f
C1038 XFE_O.NIN.n13 VSS 4.91382f
C1039 XFE_O.NIN.t15 VSS 1.60156f
C1040 XFE_O.NIN.t14 VSS 0.2973f
C1041 XFE_O.NIN.t13 VSS 0.2973f
C1042 XFE_O.NIN.n14 VSS 1.24724f
C1043 XFE_O.NIN.n15 VSS 0.70293f
C1044 XFE_O.NIN.t12 VSS 0.2973f
C1045 XFE_O.NIN.t11 VSS 0.2973f
C1046 XFE_O.NIN.n16 VSS 1.24724f
C1047 XFE_O.NIN.n17 VSS 0.29885f
C1048 XFE_O.NIN.t8 VSS 1.60156f
C1049 XFE_O.NIN.t10 VSS 0.2973f
C1050 XFE_O.NIN.t9 VSS 0.2973f
C1051 XFE_O.NIN.n18 VSS 1.24724f
C1052 XFE_O.NIN.n19 VSS 0.63197f
C1053 XFE_O.NIN.n20 VSS 0.98797f
C1054 XFE_O.NIN.n21 VSS 1.39363f
C1055 XFE_E.DN.t1 VSS 0.88596f
C1056 XFE_E.DN.t4 VSS 0.8912f
C1057 XFE_E.DN.n0 VSS 0.52546f
C1058 XFE_E.DN.n1 VSS 0.33878f
C1059 XFE_E.DN.n2 VSS 0.06346f
C1060 XFE_E.DN.n3 VSS 0.09808f
C1061 XFE_E.DN.n4 VSS 0.13746f
C1062 XFE_E.DN.n5 VSS 0.0636f
C1063 XFE_E.DN.n6 VSS 0.0636f
C1064 XFE_E.DN.n7 VSS 0.18512f
C1065 XFE_E.DN.n8 VSS 0.27157f
C1066 XFE_E.DN.n9 VSS 0.0915f
C1067 XFE_E.DN.n10 VSS 0.09808f
C1068 XFE_E.DN.n11 VSS 0.09808f
C1069 XFE_E.DN.n12 VSS 0.09808f
C1070 XFE_E.DN.n13 VSS 0.13746f
C1071 XFE_E.DN.n14 VSS 0.13746f
C1072 XFE_E.DN.n15 VSS 0.13732f
C1073 XFE_E.DN.n16 VSS 0.09808f
C1074 XFE_E.DN.n17 VSS 0.09808f
C1075 XFE_E.DN.n18 VSS 0.0894f
C1076 XFE_E.DN.n19 VSS 0.14833f
C1077 XFE_E.DN.n20 VSS 0.61121f
C1078 XFE_E.DN.t5 VSS 0.88923f
C1079 XFE_E.DN.t2 VSS 0.2868f
C1080 XFE_E.DN.t0 VSS 0.2868f
C1081 XFE_E.DN.n21 VSS 0.57969f
C1082 XFE_E.DN.n22 VSS 0.31864f
C1083 XFE_E.DN.t3 VSS 0.88738f
C1084 XFE_E.DN.n23 VSS 0.98658f
C1085 XFE_E.DN.n24 VSS 1.33585f
C1086 XFE_E.DP.n0 VSS 0.34607f
C1087 XFE_E.DP.n1 VSS 0.06467f
C1088 XFE_E.DP.n2 VSS 0.09996f
C1089 XFE_E.DP.n3 VSS 0.14009f
C1090 XFE_E.DP.n4 VSS 0.06482f
C1091 XFE_E.DP.n5 VSS 0.06482f
C1092 XFE_E.DP.n6 VSS 0.18866f
C1093 XFE_E.DP.n7 VSS 0.27676f
C1094 XFE_E.DP.n8 VSS 0.09325f
C1095 XFE_E.DP.n9 VSS 0.09996f
C1096 XFE_E.DP.n10 VSS 0.09996f
C1097 XFE_E.DP.n11 VSS 0.09996f
C1098 XFE_E.DP.n12 VSS 0.14009f
C1099 XFE_E.DP.n13 VSS 0.14009f
C1100 XFE_E.DP.n14 VSS 0.13994f
C1101 XFE_E.DP.n15 VSS 0.09996f
C1102 XFE_E.DP.n16 VSS 0.09996f
C1103 XFE_E.DP.n17 VSS 0.09111f
C1104 XFE_E.DP.n18 VSS 0.15109f
C1105 XFE_E.DP.n19 VSS 0.54741f
C1106 XFE_E.DP.t4 VSS 0.90102f
C1107 XFE_E.DP.t0 VSS 0.89965f
C1108 XFE_E.DP.n20 VSS 0.60387f
C1109 XFE_E.DP.t5 VSS 0.90157f
C1110 XFE_E.DP.t2 VSS 0.28762f
C1111 XFE_E.DP.t3 VSS 0.28762f
C1112 XFE_E.DP.n21 VSS 0.59078f
C1113 XFE_E.DP.n22 VSS 0.32473f
C1114 XFE_E.DP.t1 VSS 0.89959f
C1115 XFE_E.DP.n23 VSS 1.08581f
C1116 XFE_E.DP.n24 VSS 1.41978f
C1117 XFE_O.DP.t4 VSS 0.89965f
C1118 XFE_O.DP.t5 VSS 0.90102f
C1119 XFE_O.DP.n0 VSS 0.60387f
C1120 XFE_O.DP.t2 VSS 0.90157f
C1121 XFE_O.DP.t3 VSS 0.28762f
C1122 XFE_O.DP.t0 VSS 0.28762f
C1123 XFE_O.DP.n1 VSS 0.59078f
C1124 XFE_O.DP.n2 VSS 0.32473f
C1125 XFE_O.DP.t1 VSS 0.89959f
C1126 XFE_O.DP.n3 VSS 1.08581f
C1127 XFE_O.DP.n4 VSS 1.42483f
C1128 XFE_O.DP.n5 VSS 0.34607f
C1129 XFE_O.DP.n6 VSS 0.09111f
C1130 XFE_O.DP.n7 VSS 0.06482f
C1131 XFE_O.DP.n8 VSS 0.09996f
C1132 XFE_O.DP.n9 VSS 0.06482f
C1133 XFE_O.DP.n10 VSS 0.09996f
C1134 XFE_O.DP.n11 VSS 0.13994f
C1135 XFE_O.DP.n12 VSS 0.14009f
C1136 XFE_O.DP.n13 VSS 0.14009f
C1137 XFE_O.DP.n14 VSS 0.14009f
C1138 XFE_O.DP.n15 VSS 0.27676f
C1139 XFE_O.DP.n16 VSS 0.09325f
C1140 XFE_O.DP.n17 VSS 0.18866f
C1141 XFE_O.DP.n18 VSS 0.09996f
C1142 XFE_O.DP.n19 VSS 0.09996f
C1143 XFE_O.DP.n20 VSS 0.09996f
C1144 XFE_O.DP.n21 VSS 0.09996f
C1145 XFE_O.DP.n22 VSS 0.06467f
C1146 XFE_O.DP.n23 VSS 0.15109f
C1147 XFE_O.DP.n24 VSS 0.54719f
C1148 XFE_O.DP.n25 VSS 0.24004f
C1149 XFE_O.DN.n0 VSS 0.33878f
C1150 XFE_O.DN.n1 VSS 0.0894f
C1151 XFE_O.DN.n2 VSS 0.0636f
C1152 XFE_O.DN.n3 VSS 0.09808f
C1153 XFE_O.DN.n4 VSS 0.0636f
C1154 XFE_O.DN.n5 VSS 0.09808f
C1155 XFE_O.DN.n6 VSS 0.13732f
C1156 XFE_O.DN.n7 VSS 0.13746f
C1157 XFE_O.DN.n8 VSS 0.13746f
C1158 XFE_O.DN.n9 VSS 0.13746f
C1159 XFE_O.DN.n10 VSS 0.27157f
C1160 XFE_O.DN.n11 VSS 0.0915f
C1161 XFE_O.DN.n12 VSS 0.18512f
C1162 XFE_O.DN.n13 VSS 0.09808f
C1163 XFE_O.DN.n14 VSS 0.09808f
C1164 XFE_O.DN.n15 VSS 0.09808f
C1165 XFE_O.DN.n16 VSS 0.09808f
C1166 XFE_O.DN.n17 VSS 0.06346f
C1167 XFE_O.DN.n18 VSS 0.14833f
C1168 XFE_O.DN.n19 VSS 0.61121f
C1169 XFE_O.DN.t2 VSS 0.88923f
C1170 XFE_O.DN.t4 VSS 0.2868f
C1171 XFE_O.DN.t5 VSS 0.2868f
C1172 XFE_O.DN.n20 VSS 0.57969f
C1173 XFE_O.DN.n21 VSS 0.31864f
C1174 XFE_O.DN.t1 VSS 0.88738f
C1175 XFE_O.DN.n22 VSS 0.98658f
C1176 XFE_O.DN.n23 VSS 1.34081f
C1177 XFE_O.DN.t3 VSS 0.8912f
C1178 XFE_O.DN.t0 VSS 0.88596f
C1179 XFE_O.DN.n24 VSS 0.52459f
C1180 XFE_O.DN.n25 VSS 0.3408f
C1181 XFE_E.NTAIL.t7 VSS 0.17543f
C1182 XFE_E.NTAIL.t2 VSS 0.17394f
C1183 XFE_E.NTAIL.n0 VSS 0.61838f
C1184 XFE_E.NTAIL.t1 VSS 0.17394f
C1185 XFE_E.NTAIL.t0 VSS 0.17394f
C1186 XFE_E.NTAIL.n1 VSS 0.61345f
C1187 XFE_E.NTAIL.n2 VSS 0.32219f
C1188 XFE_E.NTAIL.t6 VSS 0.17394f
C1189 XFE_E.NTAIL.t5 VSS 0.17394f
C1190 XFE_E.NTAIL.n3 VSS 0.61345f
C1191 XFE_E.NTAIL.t4 VSS 0.17394f
C1192 XFE_E.NTAIL.t3 VSS 0.17542f
C1193 XFE_E.NTAIL.n4 VSS 0.61838f
C1194 XFE_E.NTAIL.n5 VSS 0.68153f
C1195 XFE_E.NTAIL.t31 VSS 1.01642f
C1196 XFE_E.NTAIL.t30 VSS 0.20524f
C1197 XFE_E.NTAIL.t29 VSS 0.20524f
C1198 XFE_E.NTAIL.n6 VSS 0.7709f
C1199 XFE_E.NTAIL.n7 VSS 0.36115f
C1200 XFE_E.NTAIL.t28 VSS 0.20524f
C1201 XFE_E.NTAIL.t27 VSS 0.20524f
C1202 XFE_E.NTAIL.n8 VSS 0.7709f
C1203 XFE_E.NTAIL.n9 VSS 0.18974f
C1204 XFE_E.NTAIL.t26 VSS 0.20524f
C1205 XFE_E.NTAIL.t25 VSS 0.20524f
C1206 XFE_E.NTAIL.n10 VSS 0.7709f
C1207 XFE_E.NTAIL.n11 VSS 0.18974f
C1208 XFE_E.NTAIL.t24 VSS 0.20524f
C1209 XFE_E.NTAIL.t23 VSS 0.20524f
C1210 XFE_E.NTAIL.n12 VSS 0.7709f
C1211 XFE_E.NTAIL.n13 VSS 0.18974f
C1212 XFE_E.NTAIL.t22 VSS 0.20524f
C1213 XFE_E.NTAIL.t21 VSS 0.20524f
C1214 XFE_E.NTAIL.n14 VSS 0.7709f
C1215 XFE_E.NTAIL.n15 VSS 0.15485f
C1216 XFE_E.NTAIL.t8 VSS 1.01642f
C1217 XFE_E.NTAIL.t10 VSS 0.20524f
C1218 XFE_E.NTAIL.t9 VSS 0.20524f
C1219 XFE_E.NTAIL.n16 VSS 0.7709f
C1220 XFE_E.NTAIL.n17 VSS 0.36115f
C1221 XFE_E.NTAIL.t12 VSS 0.20524f
C1222 XFE_E.NTAIL.t11 VSS 0.20524f
C1223 XFE_E.NTAIL.n18 VSS 0.7709f
C1224 XFE_E.NTAIL.n19 VSS 0.18974f
C1225 XFE_E.NTAIL.t14 VSS 0.20524f
C1226 XFE_E.NTAIL.t13 VSS 0.20524f
C1227 XFE_E.NTAIL.n20 VSS 0.7709f
C1228 XFE_E.NTAIL.n21 VSS 0.18974f
C1229 XFE_E.NTAIL.t16 VSS 0.20524f
C1230 XFE_E.NTAIL.t15 VSS 0.20524f
C1231 XFE_E.NTAIL.n22 VSS 0.7709f
C1232 XFE_E.NTAIL.n23 VSS 0.18974f
C1233 XFE_E.NTAIL.t18 VSS 0.20524f
C1234 XFE_E.NTAIL.t17 VSS 0.20524f
C1235 XFE_E.NTAIL.n24 VSS 0.7709f
C1236 XFE_E.NTAIL.n25 VSS 0.18974f
C1237 XFE_E.NTAIL.t20 VSS 0.20524f
C1238 XFE_E.NTAIL.t19 VSS 0.20524f
C1239 XFE_E.NTAIL.n26 VSS 0.7709f
C1240 XFE_E.NTAIL.n27 VSS 0.15485f
C1241 XFE_E.NTAIL.n28 VSS 0.27405f
C1242 XFE_E.NTAIL.t39 VSS 0.17523f
C1243 XFE_E.NTAIL.t38 VSS 0.17376f
C1244 XFE_E.NTAIL.n29 VSS 0.61838f
C1245 XFE_E.NTAIL.t34 VSS 0.17376f
C1246 XFE_E.NTAIL.t33 VSS 0.17376f
C1247 XFE_E.NTAIL.n30 VSS 0.61345f
C1248 XFE_E.NTAIL.n31 VSS 0.32219f
C1249 XFE_E.NTAIL.t32 VSS 0.17376f
C1250 XFE_E.NTAIL.t37 VSS 0.17376f
C1251 XFE_E.NTAIL.n32 VSS 0.61345f
C1252 XFE_E.NTAIL.t36 VSS 0.17376f
C1253 XFE_E.NTAIL.t35 VSS 0.17524f
C1254 XFE_E.NTAIL.n33 VSS 0.61838f
C1255 XFE_E.NTAIL.n34 VSS 0.68023f
C1256 XFE_E.NTAIL.n35 VSS 1.60812f
C1257 XFE_E.NTAIL.t44 VSS 1.11798f
C1258 XFE_E.NTAIL.t41 VSS 0.30981f
C1259 XFE_E.NTAIL.t40 VSS 0.31216f
C1260 XFE_E.NTAIL.n36 VSS 0.77602f
C1261 XFE_E.NTAIL.t43 VSS 0.30981f
C1262 XFE_E.NTAIL.t42 VSS 0.30981f
C1263 XFE_E.NTAIL.n37 VSS 0.7709f
C1264 XFE_E.NTAIL.n38 VSS 0.28537f
C1265 XFE_E.NTAIL.n39 VSS 0.25093f
C1266 XFE_E.NTAIL.n40 VSS 0.44253f
C1267 XFE_O.NTAIL.t44 VSS 1.01642f
C1268 XFE_O.NTAIL.t43 VSS 0.20524f
C1269 XFE_O.NTAIL.t42 VSS 0.20524f
C1270 XFE_O.NTAIL.n0 VSS 0.7709f
C1271 XFE_O.NTAIL.n1 VSS 0.36115f
C1272 XFE_O.NTAIL.t41 VSS 0.20524f
C1273 XFE_O.NTAIL.t40 VSS 0.20524f
C1274 XFE_O.NTAIL.n2 VSS 0.7709f
C1275 XFE_O.NTAIL.n3 VSS 0.18974f
C1276 XFE_O.NTAIL.t39 VSS 0.20524f
C1277 XFE_O.NTAIL.t38 VSS 0.20524f
C1278 XFE_O.NTAIL.n4 VSS 0.7709f
C1279 XFE_O.NTAIL.n5 VSS 0.18974f
C1280 XFE_O.NTAIL.t37 VSS 0.20524f
C1281 XFE_O.NTAIL.t36 VSS 0.20524f
C1282 XFE_O.NTAIL.n6 VSS 0.7709f
C1283 XFE_O.NTAIL.n7 VSS 0.18974f
C1284 XFE_O.NTAIL.t35 VSS 0.20524f
C1285 XFE_O.NTAIL.t34 VSS 0.20524f
C1286 XFE_O.NTAIL.n8 VSS 0.7709f
C1287 XFE_O.NTAIL.n9 VSS 0.18974f
C1288 XFE_O.NTAIL.t33 VSS 0.20524f
C1289 XFE_O.NTAIL.t32 VSS 0.20524f
C1290 XFE_O.NTAIL.n10 VSS 0.7709f
C1291 XFE_O.NTAIL.n11 VSS 0.15485f
C1292 XFE_O.NTAIL.t21 VSS 1.01642f
C1293 XFE_O.NTAIL.t23 VSS 0.20524f
C1294 XFE_O.NTAIL.t22 VSS 0.20524f
C1295 XFE_O.NTAIL.n12 VSS 0.7709f
C1296 XFE_O.NTAIL.n13 VSS 0.36115f
C1297 XFE_O.NTAIL.t25 VSS 0.20524f
C1298 XFE_O.NTAIL.t24 VSS 0.20524f
C1299 XFE_O.NTAIL.n14 VSS 0.7709f
C1300 XFE_O.NTAIL.n15 VSS 0.18974f
C1301 XFE_O.NTAIL.t27 VSS 0.20524f
C1302 XFE_O.NTAIL.t26 VSS 0.20524f
C1303 XFE_O.NTAIL.n16 VSS 0.7709f
C1304 XFE_O.NTAIL.n17 VSS 0.18974f
C1305 XFE_O.NTAIL.t29 VSS 0.20524f
C1306 XFE_O.NTAIL.t28 VSS 0.20524f
C1307 XFE_O.NTAIL.n18 VSS 0.7709f
C1308 XFE_O.NTAIL.n19 VSS 0.18974f
C1309 XFE_O.NTAIL.t31 VSS 0.20524f
C1310 XFE_O.NTAIL.t30 VSS 0.20524f
C1311 XFE_O.NTAIL.n20 VSS 0.7709f
C1312 XFE_O.NTAIL.n21 VSS 0.15485f
C1313 XFE_O.NTAIL.n22 VSS 0.27405f
C1314 XFE_O.NTAIL.t7 VSS 0.17543f
C1315 XFE_O.NTAIL.t6 VSS 0.17394f
C1316 XFE_O.NTAIL.n23 VSS 0.61838f
C1317 XFE_O.NTAIL.t5 VSS 0.17394f
C1318 XFE_O.NTAIL.t4 VSS 0.17394f
C1319 XFE_O.NTAIL.n24 VSS 0.61345f
C1320 XFE_O.NTAIL.t1 VSS 0.17394f
C1321 XFE_O.NTAIL.t0 VSS 0.17542f
C1322 XFE_O.NTAIL.n25 VSS 0.61838f
C1323 XFE_O.NTAIL.t3 VSS 0.17394f
C1324 XFE_O.NTAIL.t2 VSS 0.17394f
C1325 XFE_O.NTAIL.n26 VSS 0.61345f
C1326 XFE_O.NTAIL.n27 VSS 0.32219f
C1327 XFE_O.NTAIL.n28 VSS 0.68023f
C1328 XFE_O.NTAIL.n29 VSS 1.60812f
C1329 XFE_O.NTAIL.t12 VSS 0.31216f
C1330 XFE_O.NTAIL.t11 VSS 0.30981f
C1331 XFE_O.NTAIL.n30 VSS 0.77602f
C1332 XFE_O.NTAIL.t10 VSS 0.30981f
C1333 XFE_O.NTAIL.t9 VSS 0.30981f
C1334 XFE_O.NTAIL.n31 VSS 0.7709f
C1335 XFE_O.NTAIL.n32 VSS 0.28537f
C1336 XFE_O.NTAIL.t8 VSS 1.11798f
C1337 XFE_O.NTAIL.n33 VSS 0.25093f
C1338 XFE_O.NTAIL.n34 VSS 0.44781f
C1339 XFE_O.NTAIL.t20 VSS 0.17523f
C1340 XFE_O.NTAIL.t19 VSS 0.17376f
C1341 XFE_O.NTAIL.n35 VSS 0.61838f
C1342 XFE_O.NTAIL.t18 VSS 0.17376f
C1343 XFE_O.NTAIL.t17 VSS 0.17376f
C1344 XFE_O.NTAIL.n36 VSS 0.61345f
C1345 XFE_O.NTAIL.t14 VSS 0.17376f
C1346 XFE_O.NTAIL.t13 VSS 0.17524f
C1347 XFE_O.NTAIL.n37 VSS 0.61838f
C1348 XFE_O.NTAIL.t16 VSS 0.17376f
C1349 XFE_O.NTAIL.t15 VSS 0.17376f
C1350 XFE_O.NTAIL.n38 VSS 0.61345f
C1351 XFE_O.NTAIL.n39 VSS 0.32219f
C1352 XFE_O.NTAIL.n40 VSS 0.68023f
C1353 XFE_O.NTAIL.n41 VSS 0.4795f
C1354 a_n6716_3500.t1 VSS 0.46842f
C1355 a_n6716_3500.t0 VSS 0.9899f
C1356 a_n6572_3500.t2 VSS 0.52666f
C1357 a_n6572_3500.t4 VSS 0.12083f
C1358 a_n6572_3500.t5 VSS 0.12088f
C1359 a_n6572_3500.n0 VSS 0.18415f
C1360 a_n6572_3500.t1 VSS 0.38905f
C1361 a_n6572_3500.t0 VSS 0.15509f
C1362 a_n6572_3500.n1 VSS 1.38625f
C1363 a_n6572_3500.n2 VSS 0.64141f
C1364 a_n6572_3500.n3 VSS 0.84248f
C1365 a_n6572_3500.n4 VSS 2.72182f
C1366 a_n6572_3500.n5 VSS 0.25065f
C1367 a_n6572_3500.t3 VSS 0.52675f
C1368 a_n3600_5641.t0 VSS 0.49718f
C1369 a_n3600_5641.t3 VSS 0.12014f
C1370 a_n3600_5641.t4 VSS 0.1201f
C1371 a_n3600_5641.n0 VSS 0.18273f
C1372 a_n3600_5641.t2 VSS 0.3729f
C1373 a_n3600_5641.t5 VSS 0.1539f
C1374 a_n3600_5641.n1 VSS 1.37555f
C1375 a_n3600_5641.n2 VSS 0.55474f
C1376 a_n3600_5641.n3 VSS 1.07214f
C1377 a_n3600_5641.n4 VSS 2.44613f
C1378 a_n3600_5641.n5 VSS 0.28121f
C1379 a_n3600_5641.t1 VSS 0.49709f
C1380 a_n1900_5958.t1 VSS 0.5683f
C1381 a_n1900_5958.t0 VSS 1.16888f
C1382 a_484_3500.t1 VSS 0.57443f
C1383 a_484_3500.t0 VSS 1.18071f
C1384 a_5300_5958.t1 VSS 0.54596f
C1385 a_5300_5958.t0 VSS 1.13955f
C1386 a_n5052_2600.t0 VSS 0.12119f
C1387 a_n5052_2600.t6 VSS 0.04812f
C1388 a_n5052_2600.t7 VSS 0.04808f
C1389 a_n5052_2600.n0 VSS 0.10737f
C1390 a_n5052_2600.t4 VSS 0.04808f
C1391 a_n5052_2600.t5 VSS 0.04812f
C1392 a_n5052_2600.n1 VSS 0.10737f
C1393 a_n5052_2600.n2 VSS 0.98516f
C1394 a_n5052_2600.t2 VSS 0.03011f
C1395 a_n5052_2600.t1 VSS 0.03011f
C1396 a_n5052_2600.n3 VSS 0.09122f
C1397 a_n5052_2600.n4 VSS 0.46257f
C1398 a_n5052_2600.t3 VSS 0.12119f
C1399 a_n5052_n1000.t5 VSS 0.15561f
C1400 a_n5052_n1000.t4 VSS 0.15561f
C1401 a_n5052_n1000.t3 VSS 0.15561f
C1402 a_n5052_n1000.n0 VSS 0.45893f
C1403 a_n5052_n1000.n1 VSS 0.14951f
C1404 a_n5052_n1000.t2 VSS 0.65016f
C1405 a_n5052_n1000.n2 VSS 0.13501f
C1406 a_n5052_n1000.t1 VSS 0.14189f
C1407 a_n5052_n1000.t0 VSS 0.14189f
C1408 a_n5052_n1000.n3 VSS 0.50742f
C1409 a_n5052_n1000.t8 VSS 0.16772f
C1410 a_n5052_n1000.t7 VSS 0.16772f
C1411 a_n5052_n1000.n4 VSS 0.50742f
C1412 a_n5052_n1000.n5 VSS 1.21852f
C1413 a_n5052_n1000.n6 VSS 0.49183f
C1414 a_n5052_n1000.n7 VSS 0.11815f
C1415 a_n5052_n1000.n8 VSS 0.4607f
C1416 a_n5052_n1000.t6 VSS 0.15606f
C1417 a_2148_n500.t4 VSS 0.10871f
C1418 a_2148_n500.t3 VSS 0.10871f
C1419 a_2148_n500.t2 VSS 0.10871f
C1420 a_2148_n500.n0 VSS 0.28658f
C1421 a_2148_n500.n1 VSS 0.09336f
C1422 a_2148_n500.t1 VSS 0.4177f
C1423 a_2148_n500.n2 VSS 0.08431f
C1424 a_2148_n500.t0 VSS 0.08272f
C1425 a_2148_n500.t8 VSS 0.08272f
C1426 a_2148_n500.n3 VSS 0.17591f
C1427 a_2148_n500.t7 VSS 0.08306f
C1428 a_2148_n500.t6 VSS 0.08306f
C1429 a_2148_n500.n4 VSS 0.17591f
C1430 a_2148_n500.n5 VSS 0.81634f
C1431 a_2148_n500.n6 VSS 0.37461f
C1432 a_2148_n500.n7 VSS 0.07378f
C1433 a_2148_n500.n8 VSS 0.28768f
C1434 a_2148_n500.t5 VSS 0.10916f
C1435 a_n10800_n12572.n0 VSS 0.74217f
C1436 a_n10800_n12572.t0 VSS 0.12063f
C1437 a_n10800_n12572.n1 VSS 1.77193f
C1438 a_n10800_n12572.t1 VSS 0.16741f
C1439 a_n7300_n12700.t0 VSS 1.02298f
C1440 a_n7300_n12700.t3 VSS 0.97775f
C1441 a_n7300_n12700.t4 VSS 0.97215f
C1442 a_n7300_n12700.n0 VSS 0.54148f
C1443 a_n7300_n12700.t2 VSS 0.1493f
C1444 a_n7300_n12700.n1 VSS 2.1793f
C1445 a_n7300_n12700.n2 VSS 0.35701f
C1446 a_n7300_n12700.t1 VSS 1.01737f
C1447 a_n6400_n12652.t1 VSS 0.31174f
C1448 a_n6400_n12652.t2 VSS 0.26683f
C1449 a_n6400_n12652.t3 VSS 0.26683f
C1450 a_n6400_n12652.n0 VSS 0.82091f
C1451 a_n6400_n12652.t4 VSS 0.16832f
C1452 a_n6400_n12652.n1 VSS 2.87005f
C1453 a_n6400_n12652.n2 VSS 0.94209f
C1454 a_n6400_n12652.t0 VSS 0.31174f
C1455 a_n10800_n14372.n0 VSS 0.8249f
C1456 a_n10800_n14372.t0 VSS 0.12987f
C1457 a_n10800_n14372.n1 VSS 1.96946f
C1458 a_n10800_n14372.t1 VSS 0.18155f
C1459 a_n7300_n14500.t2 VSS 1.05346f
C1460 a_n7300_n14500.t0 VSS 1.01146f
C1461 a_n7300_n14500.t1 VSS 1.0057f
C1462 a_n7300_n14500.n0 VSS 0.55746f
C1463 a_n7300_n14500.t4 VSS 0.15371f
C1464 a_n7300_n14500.n1 VSS 2.24362f
C1465 a_n7300_n14500.n2 VSS 0.36754f
C1466 a_n7300_n14500.t3 VSS 1.04768f
C1467 a_n6400_n14452.t2 VSS 0.27216f
C1468 a_n6400_n14452.t1 VSS 0.16729f
C1469 a_n6400_n14452.t3 VSS 0.31383f
C1470 a_n6400_n14452.t4 VSS 0.31383f
C1471 a_n6400_n14452.n0 VSS 0.93635f
C1472 a_n6400_n14452.n1 VSS 2.85257f
C1473 a_n6400_n14452.n2 VSS 0.81591f
C1474 a_n6400_n14452.t0 VSS 0.27216f
C1475 a_n10800_n16172.n0 VSS 0.8249f
C1476 a_n10800_n16172.t0 VSS 0.12987f
C1477 a_n10800_n16172.n1 VSS 1.96946f
C1478 a_n10800_n16172.t1 VSS 0.18155f
C1479 a_n7300_n16300.t2 VSS 1.05346f
C1480 a_n7300_n16300.t4 VSS 1.01146f
C1481 a_n7300_n16300.t1 VSS 1.0057f
C1482 a_n7300_n16300.n0 VSS 0.55746f
C1483 a_n7300_n16300.t0 VSS 0.15371f
C1484 a_n7300_n16300.n1 VSS 2.24362f
C1485 a_n7300_n16300.n2 VSS 0.36754f
C1486 a_n7300_n16300.t3 VSS 1.04768f
C1487 a_n6400_n16252.t4 VSS 0.27216f
C1488 a_n6400_n16252.t0 VSS 0.16729f
C1489 a_n6400_n16252.t3 VSS 0.31383f
C1490 a_n6400_n16252.t2 VSS 0.31383f
C1491 a_n6400_n16252.n0 VSS 0.93635f
C1492 a_n6400_n16252.n1 VSS 2.85257f
C1493 a_n6400_n16252.n2 VSS 0.81591f
C1494 a_n6400_n16252.t1 VSS 0.27216f
C1495 a_n10800_n17972.n0 VSS 0.8249f
C1496 a_n10800_n17972.t0 VSS 0.12987f
C1497 a_n10800_n17972.n1 VSS 1.96946f
C1498 a_n10800_n17972.t1 VSS 0.18155f
C1499 a_n7300_n18100.t1 VSS 1.01146f
C1500 a_n7300_n18100.t2 VSS 1.0057f
C1501 a_n7300_n18100.n0 VSS 0.55746f
C1502 a_n7300_n18100.t0 VSS 0.15371f
C1503 a_n7300_n18100.n1 VSS 2.24362f
C1504 a_n7300_n18100.t4 VSS 1.04768f
C1505 a_n7300_n18100.n2 VSS 0.36754f
C1506 a_n7300_n18100.t3 VSS 1.05346f
C1507 a_n6400_n18052.t1 VSS 0.27216f
C1508 a_n6400_n18052.t2 VSS 0.16729f
C1509 a_n6400_n18052.t4 VSS 0.31383f
C1510 a_n6400_n18052.t3 VSS 0.31383f
C1511 a_n6400_n18052.n0 VSS 0.93635f
C1512 a_n6400_n18052.n1 VSS 2.85257f
C1513 a_n6400_n18052.n2 VSS 0.81591f
C1514 a_n6400_n18052.t0 VSS 0.27216f
C1515 a_n10800_n19772.n0 VSS 0.8249f
C1516 a_n10800_n19772.t0 VSS 0.12987f
C1517 a_n10800_n19772.n1 VSS 1.96946f
C1518 a_n10800_n19772.t1 VSS 0.18155f
C1519 a_n7300_n19900.t2 VSS 1.05359f
C1520 a_n7300_n19900.t4 VSS 1.01158f
C1521 a_n7300_n19900.t0 VSS 1.00582f
C1522 a_n7300_n19900.n0 VSS 0.55754f
C1523 a_n7300_n19900.t1 VSS 0.15373f
C1524 a_n7300_n19900.n1 VSS 2.24392f
C1525 a_n7300_n19900.n2 VSS 0.36759f
C1526 a_n7300_n19900.t3 VSS 1.0478f
C1527 a_n6400_n19852.t4 VSS 0.27216f
C1528 a_n6400_n19852.t0 VSS 0.16729f
C1529 a_n6400_n19852.t3 VSS 0.31383f
C1530 a_n6400_n19852.t2 VSS 0.31383f
C1531 a_n6400_n19852.n0 VSS 0.93635f
C1532 a_n6400_n19852.n1 VSS 2.85257f
C1533 a_n6400_n19852.n2 VSS 0.81591f
C1534 a_n6400_n19852.t1 VSS 0.27216f
C1535 a_n10800_n21572.n0 VSS 0.82349f
C1536 a_n10800_n21572.t0 VSS 0.12929f
C1537 a_n10800_n21572.n1 VSS 1.96608f
C1538 a_n10800_n21572.t1 VSS 0.18086f
C1539 a_n7157_n21700.t0 VSS 1.05367f
C1540 a_n7157_n21700.t2 VSS 1.01242f
C1541 a_n7157_n21700.t4 VSS 1.00665f
C1542 a_n7157_n21700.n0 VSS 0.5581f
C1543 a_n7157_n21700.t3 VSS 0.15048f
C1544 a_n7157_n21700.n1 VSS 2.16743f
C1545 a_n7157_n21700.n2 VSS 0.36796f
C1546 a_n7157_n21700.t1 VSS 1.04788f
C1547 a_n6400_n21652.t1 VSS 0.31401f
C1548 a_n6400_n21652.t3 VSS 0.27309f
C1549 a_n6400_n21652.t4 VSS 0.27309f
C1550 a_n6400_n21652.n0 VSS 0.82003f
C1551 a_n6400_n21652.t2 VSS 0.16442f
C1552 a_n6400_n21652.n1 VSS 2.78096f
C1553 a_n6400_n21652.n2 VSS 0.94109f
C1554 a_n6400_n21652.t0 VSS 0.31401f
C1555 a_n10800_n23372.n0 VSS 0.78687f
C1556 a_n10800_n23372.t0 VSS 0.12249f
C1557 a_n10800_n23372.n1 VSS 1.87865f
C1558 a_n10800_n23372.t1 VSS 0.17169f
C1559 a_n7157_n23500.t0 VSS 0.94316f
C1560 a_n7157_n23500.t2 VSS 0.9378f
C1561 a_n7157_n23500.n0 VSS 0.51899f
C1562 a_n7157_n23500.t1 VSS 0.13994f
C1563 a_n7157_n23500.n1 VSS 2.01556f
C1564 a_n7157_n23500.t4 VSS 0.97513f
C1565 a_n7157_n23500.n2 VSS 0.34218f
C1566 a_n7157_n23500.t3 VSS 0.98051f
C1567 a_n6400_n23452.t2 VSS 0.26779f
C1568 a_n6400_n23452.t1 VSS 0.16253f
C1569 a_n6400_n23452.t3 VSS 0.30483f
C1570 a_n6400_n23452.t4 VSS 0.30483f
C1571 a_n6400_n23452.n0 VSS 0.93029f
C1572 a_n6400_n23452.n1 VSS 2.74905f
C1573 a_n6400_n23452.n2 VSS 0.81062f
C1574 a_n6400_n23452.t0 VSS 0.26779f
C1575 VSS.t263 VSS 0.12568f
C1576 VSS.t265 VSS 0.12332f
C1577 VSS.t292 VSS 0.12332f
C1578 VSS.t294 VSS 0.12332f
C1579 VSS.t66 VSS 0.14369f
C1580 VSS.t227 VSS 0.16292f
C1581 VSS.t221 VSS 0.16057f
C1582 VSS.t219 VSS 0.16057f
C1583 VSS.t225 VSS 0.16057f
C1584 VSS.t223 VSS 0.16057f
C1585 VSS.t302 VSS 0.17678f
C1586 VSS.t304 VSS 0.17682f
C1587 VSS.t23 VSS 0.11864f
C1588 VSS.t25 VSS 0.11641f
C1589 VSS.t71 VSS 0.11641f
C1590 VSS.t73 VSS 0.11641f
C1591 VSS.t363 VSS 0.07078f
C1592 VSS.t185 VSS 0.07271f
C1593 VSS.t232 VSS 0.07078f
C1594 VSS.t230 VSS 0.07078f
C1595 VSS.t200 VSS 0.07078f
C1596 VSS.t210 VSS 0.07078f
C1597 VSS.t198 VSS 0.0727f
C1598 VSS.t355 VSS 0.07078f
C1599 VSS.t296 VSS 0.15863f
C1600 VSS.t352 VSS 0.05718f
C1601 VSS.t350 VSS 0.056f
C1602 VSS.t348 VSS 0.056f
C1603 VSS.t346 VSS 0.056f
C1604 VSS.t344 VSS 0.056f
C1605 VSS.t342 VSS 0.056f
C1606 VSS.t340 VSS 0.056f
C1607 VSS.t339 VSS 0.056f
C1608 VSS.t338 VSS 0.056f
C1609 VSS.t336 VSS 0.056f
C1610 VSS.t310 VSS 0.056f
C1611 VSS.t308 VSS 0.05718f
C1612 VSS.t314 VSS 0.056f
C1613 VSS.t312 VSS 0.056f
C1614 VSS.t318 VSS 0.056f
C1615 VSS.t316 VSS 0.056f
C1616 VSS.t322 VSS 0.056f
C1617 VSS.t320 VSS 0.056f
C1618 VSS.t328 VSS 0.056f
C1619 VSS.t326 VSS 0.056f
C1620 VSS.t332 VSS 0.056f
C1621 VSS.t330 VSS 0.056f
C1622 VSS.t334 VSS 0.056f
C1623 VSS.t324 VSS 0.056f
C1624 VSS.t59 VSS 0.17816f
C1625 VSS.t6 VSS 0.17813f
C1626 VSS.t270 VSS 0.06945f
C1627 VSS.t367 VSS 0.07134f
C1628 VSS.t359 VSS 0.06945f
C1629 VSS.t208 VSS 0.06945f
C1630 VSS.t206 VSS 0.06945f
C1631 VSS.t76 VSS 0.06945f
C1632 VSS.t361 VSS 0.07134f
C1633 VSS.t272 VSS 0.06945f
C1634 VSS.t368 VSS 0.05093f
C1635 VSS.t21 VSS 0.05439f
C1636 VSS.t96 VSS 0.05484f
C1637 VSS.t353 VSS 0.05484f
C1638 VSS.t254 VSS 0.05484f
C1639 VSS.t255 VSS 0.05484f
C1640 VSS.t3 VSS 0.05312f
C1641 VSS.t170 VSS 0.05718f
C1642 VSS.t168 VSS 0.056f
C1643 VSS.t166 VSS 0.056f
C1644 VSS.t164 VSS 0.056f
C1645 VSS.t162 VSS 0.056f
C1646 VSS.t160 VSS 0.056f
C1647 VSS.t158 VSS 0.056f
C1648 VSS.t156 VSS 0.056f
C1649 VSS.t154 VSS 0.056f
C1650 VSS.t152 VSS 0.056f
C1651 VSS.t150 VSS 0.056f
C1652 VSS.t148 VSS 0.056f
C1653 VSS.t146 VSS 0.056f
C1654 VSS.t144 VSS 0.056f
C1655 VSS.t204 VSS 0.17682f
C1656 VSS.t12 VSS 0.17678f
C1657 VSS.t370 VSS 0.11641f
C1658 VSS.t372 VSS 0.11641f
C1659 VSS.t31 VSS 0.11641f
C1660 VSS.t33 VSS 0.11864f
C1661 VSS.t120 VSS 0.07271f
C1662 VSS.t41 VSS 0.07078f
C1663 VSS.t174 VSS 0.07078f
C1664 VSS.t14 VSS 0.07078f
C1665 VSS.t43 VSS 0.07078f
C1666 VSS.t365 VSS 0.07078f
C1667 VSS.t116 VSS 0.07078f
C1668 VSS.t176 VSS 0.0727f
C1669 VSS.t192 VSS 0.15863f
C1670 VSS.t282 VSS 0.16057f
C1671 VSS.t280 VSS 0.16057f
C1672 VSS.t274 VSS 0.16057f
C1673 VSS.t278 VSS 0.16057f
C1674 VSS.t276 VSS 0.16292f
C1675 VSS.t10 VSS 0.17813f
C1676 VSS.t37 VSS 0.17816f
C1677 VSS.t142 VSS 0.056f
C1678 VSS.t140 VSS 0.056f
C1679 VSS.t128 VSS 0.056f
C1680 VSS.t126 VSS 0.05718f
C1681 VSS.t132 VSS 0.056f
C1682 VSS.t130 VSS 0.056f
C1683 VSS.t136 VSS 0.056f
C1684 VSS.t134 VSS 0.056f
C1685 VSS.t138 VSS 0.056f
C1686 VSS.t137 VSS 0.056f
C1687 VSS.t29 VSS 0.14369f
C1688 VSS.t118 VSS 0.07134f
C1689 VSS.t261 VSS 0.06945f
C1690 VSS.t357 VSS 0.06945f
C1691 VSS.t288 VSS 0.06945f
C1692 VSS.t259 VSS 0.06945f
C1693 VSS.t300 VSS 0.06945f
C1694 VSS.t290 VSS 0.06945f
C1695 VSS.t234 VSS 0.07134f
C1696 VSS.t285 VSS 0.12332f
C1697 VSS.t18 VSS 0.12332f
C1698 VSS.t56 VSS 0.12332f
C1699 VSS.t124 VSS 0.12568f
C1700 VSS.t110 VSS 0.03072f
C1701 VSS.t108 VSS 0.03072f
C1702 VSS.t109 VSS 0.03117f
C1703 VSS.t102 VSS 0.03072f
C1704 VSS.t103 VSS 0.03117f
C1705 VSS.t112 VSS 0.03117f
C1706 VSS.t114 VSS 0.03072f
C1707 VSS.t113 VSS 0.03072f
C1708 VSS.t100 VSS 0.03072f
C1709 VSS.t111 VSS 0.03117f
C1710 VDD.t303 VSS 0.57497f
C1711 VDD.t302 VSS 0.51748f
C1712 VDD.t27 VSS 0.51748f
C1713 VDD.t26 VSS 0.51748f
C1714 VDD.t70 VSS 0.51748f
C1715 VDD.t69 VSS 0.51748f
C1716 VDD.t299 VSS 0.51748f
C1717 VDD.t298 VSS 0.51748f
C1718 VDD.t179 VSS 0.51748f
C1719 VDD.t178 VSS 0.51748f
C1720 VDD.t183 VSS 0.51748f
C1721 VDD.t182 VSS 0.51748f
C1722 VDD.t3 VSS 0.51748f
C1723 VDD.t2 VSS 0.29173f
C1724 VDD.t1 VSS 0.07567f
C1725 VDD.t181 VSS 0.07751f
C1726 VDD.n0 VSS 0.06505f
C1727 VDD.t0 VSS 0.37957f
C1728 VDD.t176 VSS 0.26278f
C1729 VDD.t177 VSS 0.07751f
C1730 VDD.t297 VSS 0.07751f
C1731 VDD.n1 VSS 0.06505f
C1732 VDD.t67 VSS 0.26278f
C1733 VDD.t68 VSS 0.07751f
C1734 VDD.t25 VSS 0.07703f
C1735 VDD.n2 VSS 0.06505f
C1736 VDD.t300 VSS 0.27226f
C1737 VDD.t301 VSS 0.07331f
C1738 VDD.n3 VSS 0.28175f
C1739 VDD.n4 VSS 0.04491f
C1740 VDD.n5 VSS 0.26941f
C1741 VDD.t24 VSS 0.26278f
C1742 VDD.n6 VSS 0.26941f
C1743 VDD.n7 VSS 0.04491f
C1744 VDD.n8 VSS 0.06505f
C1745 VDD.n9 VSS 0.04491f
C1746 VDD.n10 VSS 0.26941f
C1747 VDD.t296 VSS 0.26278f
C1748 VDD.n11 VSS 0.26941f
C1749 VDD.n12 VSS 0.04491f
C1750 VDD.n13 VSS 0.06505f
C1751 VDD.n14 VSS 0.04491f
C1752 VDD.n15 VSS 0.26941f
C1753 VDD.t180 VSS 0.26278f
C1754 VDD.n16 VSS 0.26941f
C1755 VDD.n17 VSS 0.04491f
C1756 VDD.n18 VSS 0.15301f
C1757 VDD.n19 VSS 2.13675f
C1758 VDD.n20 VSS 11.9221f
C1759 VDD.t49 VSS 1.14546f
C1760 VDD.t50 VSS 1.37455f
C1761 VDD.t51 VSS 1.37455f
C1762 VDD.t52 VSS 1.05233f
C1763 VDD.t160 VSS 0.0249f
C1764 VDD.t48 VSS 0.02745f
C1765 VDD.n21 VSS 0.16488f
C1766 VDD.t171 VSS 0.02745f
C1767 VDD.n22 VSS 0.08415f
C1768 VDD.t61 VSS 0.02374f
C1769 VDD.n23 VSS 0.10436f
C1770 VDD.t185 VSS 0.02374f
C1771 VDD.n24 VSS 0.31098f
C1772 VDD.t73 VSS 0.02942f
C1773 VDD.n25 VSS 0.30959f
C1774 VDD.t62 VSS 0.02942f
C1775 VDD.n26 VSS 0.30959f
C1776 VDD.t184 VSS 0.02374f
C1777 VDD.n27 VSS 0.23058f
C1778 VDD.n28 VSS 4.38666f
C1779 VDD.n29 VSS 0.36468f
C1780 VDD.n30 VSS 0.08453f
C1781 VDD.n31 VSS 0.08086f
C1782 VDD.n32 VSS 0.36697f
C1783 VDD.t272 VSS 0.53904f
C1784 VDD.n33 VSS 0.08086f
C1785 VDD.n34 VSS 0.36468f
C1786 VDD.n35 VSS 0.36468f
C1787 VDD.n36 VSS 0.36468f
C1788 VDD.n37 VSS 0.08453f
C1789 VDD.n38 VSS 0.08086f
C1790 VDD.t274 VSS 0.43123f
C1791 VDD.t276 VSS 2.15615f
C1792 VDD.n39 VSS 4.78474f
C1793 VDD.t150 VSS 0.21562f
C1794 VDD.n40 VSS 0.2285f
C1795 VDD.t134 VSS 1.50931f
C1796 VDD.t286 VSS 1.94054f
C1797 VDD.n41 VSS 0.08086f
C1798 VDD.n42 VSS 0.08086f
C1799 VDD.n43 VSS 0.08453f
C1800 VDD.n44 VSS 0.36468f
C1801 VDD.t8 VSS 0.21562f
C1802 VDD.t148 VSS 0.21562f
C1803 VDD.t55 VSS 0.21562f
C1804 VDD.t144 VSS 0.21562f
C1805 VDD.t57 VSS 0.21562f
C1806 VDD.t140 VSS 0.21562f
C1807 VDD.t20 VSS 0.21562f
C1808 VDD.t142 VSS 0.75465f
C1809 VDD.t136 VSS 0.43123f
C1810 VDD.t100 VSS 0.43123f
C1811 VDD.t138 VSS 0.43123f
C1812 VDD.n45 VSS 2.04834f
C1813 VDD.t194 VSS 2.04834f
C1814 VDD.t192 VSS 0.43123f
C1815 VDD.t290 VSS 0.43123f
C1816 VDD.t288 VSS 0.43123f
C1817 VDD.n46 VSS 0.86246f
C1818 VDD.n47 VSS 0.08086f
C1819 VDD.n48 VSS 0.08453f
C1820 VDD.n49 VSS 0.36468f
C1821 VDD.n50 VSS 0.36468f
C1822 VDD.n51 VSS 0.36468f
C1823 VDD.n52 VSS 0.36468f
C1824 VDD.n53 VSS 0.36468f
C1825 VDD.n54 VSS 0.08453f
C1826 VDD.n55 VSS 0.08086f
C1827 VDD.t133 VSS 2.04834f
C1828 VDD.t132 VSS 0.43123f
C1829 VDD.t131 VSS 0.43123f
C1830 VDD.t130 VSS 0.32342f
C1831 VDD.n56 VSS 0.21562f
C1832 VDD.t129 VSS 0.32342f
C1833 VDD.t128 VSS 0.43123f
C1834 VDD.t127 VSS 0.43123f
C1835 VDD.t126 VSS 2.04834f
C1836 VDD.t22 VSS 1.94054f
C1837 VDD.t116 VSS 0.75465f
C1838 VDD.n57 VSS 0.08086f
C1839 VDD.n58 VSS 0.36468f
C1840 VDD.n59 VSS 0.36468f
C1841 VDD.n60 VSS 0.36468f
C1842 VDD.n61 VSS 0.36468f
C1843 VDD.n62 VSS 0.08453f
C1844 VDD.n63 VSS 0.08086f
C1845 VDD.t198 VSS 1.50931f
C1846 VDD.t292 VSS 0.21562f
C1847 VDD.t114 VSS 0.21562f
C1848 VDD.t294 VSS 0.21562f
C1849 VDD.t112 VSS 0.21562f
C1850 VDD.t188 VSS 0.21562f
C1851 VDD.t110 VSS 0.21562f
C1852 VDD.t190 VSS 0.21562f
C1853 VDD.t108 VSS 0.21562f
C1854 VDD.t282 VSS 0.43123f
C1855 VDD.t280 VSS 0.43123f
C1856 VDD.t278 VSS 0.97027f
C1857 VDD.n64 VSS 0.86246f
C1858 VDD.t96 VSS 0.32342f
C1859 VDD.t98 VSS 0.43123f
C1860 VDD.t102 VSS 0.43123f
C1861 VDD.t104 VSS 0.43123f
C1862 VDD.t106 VSS 0.32342f
C1863 VDD.n65 VSS 0.36463f
C1864 VDD.n66 VSS 0.2285f
C1865 VDD.n67 VSS 0.2285f
C1866 VDD.n68 VSS 3.77326f
C1867 VDD.n69 VSS 0.08086f
C1868 VDD.n70 VSS 0.36468f
C1869 VDD.n71 VSS 0.36468f
C1870 VDD.n72 VSS 0.31077f
C1871 VDD.n73 VSS 0.18446f
C1872 VDD.n74 VSS 0.08453f
C1873 VDD.n75 VSS 0.08086f
C1874 VDD.t31 VSS 0.12798f
C1875 VDD.t41 VSS 0.12575f
C1876 VDD.n76 VSS 0.04874f
C1877 VDD.t43 VSS 0.17558f
C1878 VDD.n77 VSS 0.13482f
C1879 VDD.n78 VSS 0.30034f
C1880 VDD.n79 VSS 0.12937f
C1881 VDD.t17 VSS 0.18616f
C1882 VDD.t89 VSS 0.18283f
C1883 VDD.n80 VSS 0.04874f
C1884 VDD.t91 VSS 0.18283f
C1885 VDD.t269 VSS 0.18283f
C1886 VDD.n81 VSS 0.04836f
C1887 VDD.n82 VSS 0.12901f
C1888 VDD.n83 VSS 0.19232f
C1889 VDD.n84 VSS 0.12937f
C1890 VDD.t265 VSS 0.10401f
C1891 VDD.t263 VSS 0.10401f
C1892 VDD.n85 VSS 0.04874f
C1893 VDD.t261 VSS 0.10401f
C1894 VDD.t251 VSS 0.10401f
C1895 VDD.n86 VSS 0.04836f
C1896 VDD.n87 VSS 0.02451f
C1897 VDD.t259 VSS 0.10401f
C1898 VDD.t257 VSS 0.10401f
C1899 VDD.n88 VSS 0.04836f
C1900 VDD.n89 VSS 0.01388f
C1901 VDD.t255 VSS 0.10401f
C1902 VDD.t253 VSS 0.10401f
C1903 VDD.n90 VSS 0.04836f
C1904 VDD.n91 VSS 0.01388f
C1905 VDD.t249 VSS 0.10401f
C1906 VDD.t241 VSS 0.10658f
C1907 VDD.n92 VSS 0.04836f
C1908 VDD.n93 VSS 0.18864f
C1909 VDD.n94 VSS 0.13623f
C1910 VDD.t271 VSS 0.18612f
C1911 VDD.t77 VSS 0.18616f
C1912 VDD.n95 VSS 0.10678f
C1913 VDD.n96 VSS 0.14498f
C1914 VDD.n97 VSS 0.12937f
C1915 VDD.t60 VSS 0.18416f
C1916 VDD.t29 VSS 0.18416f
C1917 VDD.n98 VSS 0.04846f
C1918 VDD.t11 VSS 0.18416f
C1919 VDD.t39 VSS 0.18751f
C1920 VDD.n99 VSS 0.04856f
C1921 VDD.n100 VSS 0.12909f
C1922 VDD.n101 VSS 0.17567f
C1923 VDD.t7 VSS 0.13503f
C1924 VDD.t162 VSS 0.13266f
C1925 VDD.n102 VSS 0.04874f
C1926 VDD.t5 VSS 0.18249f
C1927 VDD.n103 VSS 0.14246f
C1928 VDD.n104 VSS 0.60048f
C1929 VDD.t213 VSS 0.10658f
C1930 VDD.t221 VSS 0.10401f
C1931 VDD.n105 VSS 0.04874f
C1932 VDD.t219 VSS 0.10401f
C1933 VDD.t217 VSS 0.10401f
C1934 VDD.n106 VSS 0.04836f
C1935 VDD.n107 VSS 0.02451f
C1936 VDD.t215 VSS 0.10401f
C1937 VDD.t211 VSS 0.10401f
C1938 VDD.n108 VSS 0.04836f
C1939 VDD.n109 VSS 0.01388f
C1940 VDD.t209 VSS 0.10401f
C1941 VDD.t203 VSS 0.10401f
C1942 VDD.n110 VSS 0.04836f
C1943 VDD.n111 VSS 0.01388f
C1944 VDD.t207 VSS 0.10401f
C1945 VDD.t205 VSS 0.10401f
C1946 VDD.n112 VSS 0.04836f
C1947 VDD.n113 VSS 0.19893f
C1948 VDD.n114 VSS 0.14952f
C1949 VDD.t13 VSS 0.12798f
C1950 VDD.t15 VSS 0.12575f
C1951 VDD.n115 VSS 0.04874f
C1952 VDD.t168 VSS 0.12575f
C1953 VDD.t170 VSS 0.12575f
C1954 VDD.n116 VSS 0.04836f
C1955 VDD.n117 VSS 0.12901f
C1956 VDD.n118 VSS 0.22429f
C1957 VDD.n119 VSS 0.0772f
C1958 VDD.n120 VSS 0.43493f
C1959 VDD.n121 VSS 0.12937f
C1960 VDD.n122 VSS 0.02156f
C1961 VDD.t79 VSS 0.18616f
C1962 VDD.t33 VSS 0.18283f
C1963 VDD.n123 VSS 0.04874f
C1964 VDD.t35 VSS 0.18283f
C1965 VDD.t54 VSS 0.18283f
C1966 VDD.n124 VSS 0.04836f
C1967 VDD.n125 VSS 0.08572f
C1968 VDD.n126 VSS 0.12298f
C1969 VDD.n127 VSS 0.05929f
C1970 VDD.t229 VSS 0.14158f
C1971 VDD.t227 VSS 0.13909f
C1972 VDD.n128 VSS 0.04874f
C1973 VDD.t225 VSS 0.13909f
C1974 VDD.t223 VSS 0.13909f
C1975 VDD.n129 VSS 0.04836f
C1976 VDD.n130 VSS 0.10421f
C1977 VDD.n131 VSS 0.14725f
C1978 VDD.n132 VSS 0.05929f
C1979 VDD.n133 VSS 0.12937f
C1980 VDD.n134 VSS 0.12937f
C1981 VDD.n135 VSS 0.08625f
C1982 VDD.t267 VSS 0.18751f
C1983 VDD.t187 VSS 0.18747f
C1984 VDD.n136 VSS 0.1049f
C1985 VDD.n137 VSS 0.14413f
C1986 VDD.n138 VSS 0.04851f
C1987 VDD.t243 VSS 0.14158f
C1988 VDD.t247 VSS 0.13909f
C1989 VDD.n139 VSS 0.04874f
C1990 VDD.t245 VSS 0.13909f
C1991 VDD.t239 VSS 0.13909f
C1992 VDD.n140 VSS 0.04836f
C1993 VDD.n141 VSS 0.10421f
C1994 VDD.n142 VSS 0.14294f
C1995 VDD.t175 VSS 0.18751f
C1996 VDD.t197 VSS 0.18416f
C1997 VDD.n143 VSS 0.04874f
C1998 VDD.t201 VSS 0.18416f
C1999 VDD.t173 VSS 0.18416f
C2000 VDD.n144 VSS 0.04836f
C2001 VDD.n145 VSS 0.07941f
C2002 VDD.n146 VSS 0.11599f
C2003 VDD.n147 VSS 0.04352f
C2004 VDD.n148 VSS 0.12937f
C2005 VDD.n149 VSS 0.12937f
C2006 VDD.n150 VSS 0.0539f
C2007 VDD.t87 VSS 0.13266f
C2008 VDD.t19 VSS 0.13266f
C2009 VDD.n151 VSS 0.04874f
C2010 VDD.t37 VSS 0.13266f
C2011 VDD.t75 VSS 0.13503f
C2012 VDD.n152 VSS 0.04836f
C2013 VDD.n153 VSS 0.12901f
C2014 VDD.n154 VSS 0.17205f
C2015 VDD.n155 VSS 0.11212f
C2016 VDD.n156 VSS 0.07654f
C2017 VDD.n157 VSS 0.17173f
C2018 VDD.n158 VSS 0.13526f
C2019 VDD.n159 VSS 0.14049f
C2020 VDD.n160 VSS 0.16474f
C2021 VDD.t30 VSS 0.53904f
C2022 VDD.n161 VSS 0.08086f
C2023 VDD.n162 VSS 0.31077f
C2024 VDD.n163 VSS 0.36468f
C2025 VDD.n164 VSS 0.36468f
C2026 VDD.n165 VSS 0.36468f
C2027 VDD.n166 VSS 0.08453f
C2028 VDD.n167 VSS 0.08086f
C2029 VDD.t40 VSS 0.43123f
C2030 VDD.t42 VSS 2.15615f
C2031 VDD.n168 VSS 4.78474f
C2032 VDD.t256 VSS 0.21562f
C2033 VDD.n169 VSS 0.2285f
C2034 VDD.n170 VSS 0.2285f
C2035 VDD.t238 VSS 1.50931f
C2036 VDD.t186 VSS 1.94054f
C2037 VDD.n171 VSS 0.08086f
C2038 VDD.n172 VSS 0.08086f
C2039 VDD.n173 VSS 0.08453f
C2040 VDD.n174 VSS 0.36468f
C2041 VDD.t16 VSS 0.21562f
C2042 VDD.t254 VSS 0.21562f
C2043 VDD.t88 VSS 0.21562f
C2044 VDD.t252 VSS 0.21562f
C2045 VDD.t90 VSS 0.21562f
C2046 VDD.t248 VSS 0.21562f
C2047 VDD.t268 VSS 0.21562f
C2048 VDD.t240 VSS 0.75465f
C2049 VDD.t244 VSS 0.43123f
C2050 VDD.t246 VSS 0.43123f
C2051 VDD.t242 VSS 0.43123f
C2052 VDD.n175 VSS 2.04834f
C2053 VDD.t172 VSS 2.04834f
C2054 VDD.t200 VSS 0.43123f
C2055 VDD.t196 VSS 0.43123f
C2056 VDD.t174 VSS 0.43123f
C2057 VDD.n176 VSS 0.86246f
C2058 VDD.n177 VSS 0.08086f
C2059 VDD.n178 VSS 0.08453f
C2060 VDD.n179 VSS 0.36468f
C2061 VDD.n180 VSS 0.36468f
C2062 VDD.n181 VSS 0.36468f
C2063 VDD.n182 VSS 0.36468f
C2064 VDD.n183 VSS 0.36468f
C2065 VDD.n184 VSS 0.08453f
C2066 VDD.n185 VSS 0.08086f
C2067 VDD.t237 VSS 2.04834f
C2068 VDD.t236 VSS 0.43123f
C2069 VDD.t235 VSS 0.43123f
C2070 VDD.t234 VSS 0.32342f
C2071 VDD.n186 VSS 0.21562f
C2072 VDD.t233 VSS 0.32342f
C2073 VDD.t232 VSS 0.43123f
C2074 VDD.t231 VSS 0.43123f
C2075 VDD.t230 VSS 2.04834f
C2076 VDD.t270 VSS 1.94054f
C2077 VDD.t212 VSS 0.75465f
C2078 VDD.n187 VSS 0.08086f
C2079 VDD.n188 VSS 0.36468f
C2080 VDD.n189 VSS 0.36468f
C2081 VDD.n190 VSS 0.36468f
C2082 VDD.n191 VSS 0.36468f
C2083 VDD.n192 VSS 0.08453f
C2084 VDD.n193 VSS 0.08086f
C2085 VDD.t169 VSS 1.50931f
C2086 VDD.t59 VSS 0.21562f
C2087 VDD.t220 VSS 0.21562f
C2088 VDD.t28 VSS 0.21562f
C2089 VDD.t218 VSS 0.21562f
C2090 VDD.t10 VSS 0.21562f
C2091 VDD.t216 VSS 0.21562f
C2092 VDD.t38 VSS 0.21562f
C2093 VDD.t214 VSS 0.21562f
C2094 VDD.t167 VSS 0.43123f
C2095 VDD.t14 VSS 0.43123f
C2096 VDD.t12 VSS 0.97027f
C2097 VDD.n194 VSS 0.86246f
C2098 VDD.t204 VSS 0.32342f
C2099 VDD.t206 VSS 0.43123f
C2100 VDD.t202 VSS 0.43123f
C2101 VDD.t208 VSS 0.43123f
C2102 VDD.t210 VSS 0.32342f
C2103 VDD.n195 VSS 0.36463f
C2104 VDD.n196 VSS 0.2285f
C2105 VDD.n197 VSS 0.36698f
C2106 VDD.n198 VSS 3.77326f
C2107 VDD.n199 VSS 0.08086f
C2108 VDD.n200 VSS 0.36468f
C2109 VDD.n201 VSS 0.36468f
C2110 VDD.n202 VSS 0.36468f
C2111 VDD.n203 VSS 6.68276f
C2112 VDD.n204 VSS 3.11046f
C2113 VDD.n205 VSS 4.12141f
C2114 VDD.n206 VSS 0.06836f
C2115 VDD.n207 VSS 0.08453f
C2116 VDD.n208 VSS 0.08453f
C2117 VDD.n209 VSS 0.08086f
C2118 VDD.n210 VSS 3.01861f
C2119 VDD.t4 VSS 0.53904f
C2120 VDD.t161 VSS 0.43123f
C2121 VDD.t6 VSS 2.15615f
C2122 VDD.n211 VSS 4.78474f
C2123 VDD.n212 VSS 3.98888f
C2124 VDD.n213 VSS 0.08086f
C2125 VDD.n214 VSS 0.08453f
C2126 VDD.n215 VSS 0.08453f
C2127 VDD.n216 VSS 0.08453f
C2128 VDD.n217 VSS 0.08086f
C2129 VDD.n218 VSS 0.86246f
C2130 VDD.t53 VSS 0.43123f
C2131 VDD.t34 VSS 0.43123f
C2132 VDD.t32 VSS 0.43123f
C2133 VDD.t78 VSS 2.04834f
C2134 VDD.n219 VSS 2.04834f
C2135 VDD.t222 VSS 0.43123f
C2136 VDD.t224 VSS 0.43123f
C2137 VDD.t226 VSS 0.43123f
C2138 VDD.t228 VSS 1.50931f
C2139 VDD.n220 VSS 1.87393f
C2140 VDD.t76 VSS 0.53904f
C2141 VDD.n221 VSS 0.21562f
C2142 VDD.n222 VSS 0.08086f
C2143 VDD.n223 VSS 0.08453f
C2144 VDD.n224 VSS 0.08453f
C2145 VDD.n225 VSS 0.08453f
C2146 VDD.n226 VSS 0.08086f
C2147 VDD.n227 VSS 0.21562f
C2148 VDD.t266 VSS 0.53904f
C2149 VDD.n228 VSS 1.87393f
C2150 VDD.n229 VSS 0.2285f
C2151 VDD.n230 VSS 0.2285f
C2152 VDD.n231 VSS 0.36463f
C2153 VDD.t258 VSS 0.32342f
C2154 VDD.t250 VSS 0.43123f
C2155 VDD.t260 VSS 0.43123f
C2156 VDD.t262 VSS 0.43123f
C2157 VDD.t264 VSS 0.32342f
C2158 VDD.n232 VSS 0.86246f
C2159 VDD.t74 VSS 0.97027f
C2160 VDD.t36 VSS 0.43123f
C2161 VDD.t18 VSS 0.43123f
C2162 VDD.t86 VSS 1.50931f
C2163 VDD.n233 VSS 3.98888f
C2164 VDD.n234 VSS 0.08086f
C2165 VDD.n235 VSS 0.08453f
C2166 VDD.n236 VSS 0.08453f
C2167 VDD.n237 VSS 0.08453f
C2168 VDD.n238 VSS 0.08086f
C2169 VDD.n239 VSS 3.01861f
C2170 VDD.n240 VSS 3.77326f
C2171 VDD.n241 VSS 3.09978f
C2172 VDD.n242 VSS 4.12141f
C2173 VDD.n243 VSS 0.06836f
C2174 VDD.n244 VSS 1.06543f
C2175 VDD.n245 VSS 1.06543f
C2176 VDD.n246 VSS 0.17173f
C2177 VDD.t279 VSS 0.13503f
C2178 VDD.t281 VSS 0.13266f
C2179 VDD.n247 VSS 0.04836f
C2180 VDD.t283 VSS 0.13266f
C2181 VDD.t199 VSS 0.13266f
C2182 VDD.n248 VSS 0.04874f
C2183 VDD.n249 VSS 0.12901f
C2184 VDD.n250 VSS 0.17205f
C2185 VDD.n251 VSS 0.12937f
C2186 VDD.t23 VSS 0.18747f
C2187 VDD.t93 VSS 0.18751f
C2188 VDD.n252 VSS 0.1049f
C2189 VDD.n253 VSS 0.14413f
C2190 VDD.n254 VSS 0.12937f
C2191 VDD.t193 VSS 0.18283f
C2192 VDD.t195 VSS 0.18616f
C2193 VDD.n255 VSS 0.04874f
C2194 VDD.t289 VSS 0.18283f
C2195 VDD.t291 VSS 0.18283f
C2196 VDD.n256 VSS 0.04836f
C2197 VDD.n257 VSS 0.08572f
C2198 VDD.n258 VSS 0.12298f
C2199 VDD.n259 VSS 0.43491f
C2200 VDD.t275 VSS 0.13266f
C2201 VDD.t277 VSS 0.13503f
C2202 VDD.n260 VSS 0.04874f
C2203 VDD.t273 VSS 0.18249f
C2204 VDD.n261 VSS 0.14246f
C2205 VDD.n262 VSS 0.6005f
C2206 VDD.t64 VSS 0.12575f
C2207 VDD.t66 VSS 0.12575f
C2208 VDD.n263 VSS 0.04836f
C2209 VDD.t45 VSS 0.12575f
C2210 VDD.t47 VSS 0.12798f
C2211 VDD.n264 VSS 0.04874f
C2212 VDD.n265 VSS 0.12901f
C2213 VDD.n266 VSS 0.22429f
C2214 VDD.n267 VSS 0.0772f
C2215 VDD.t141 VSS 0.10401f
C2216 VDD.t143 VSS 0.10658f
C2217 VDD.n268 VSS 0.04874f
C2218 VDD.t149 VSS 0.10401f
C2219 VDD.t145 VSS 0.10401f
C2220 VDD.n269 VSS 0.04836f
C2221 VDD.n270 VSS 0.02451f
C2222 VDD.t147 VSS 0.10401f
C2223 VDD.t151 VSS 0.10401f
C2224 VDD.n271 VSS 0.04836f
C2225 VDD.n272 VSS 0.01388f
C2226 VDD.t155 VSS 0.10401f
C2227 VDD.t153 VSS 0.10401f
C2228 VDD.n273 VSS 0.04836f
C2229 VDD.n274 VSS 0.01388f
C2230 VDD.t159 VSS 0.10401f
C2231 VDD.t157 VSS 0.10401f
C2232 VDD.n275 VSS 0.04836f
C2233 VDD.n276 VSS 0.19893f
C2234 VDD.n277 VSS 0.14952f
C2235 VDD.t9 VSS 0.18751f
C2236 VDD.t56 VSS 0.18416f
C2237 VDD.n278 VSS 0.04856f
C2238 VDD.t58 VSS 0.18416f
C2239 VDD.t21 VSS 0.18416f
C2240 VDD.n279 VSS 0.04846f
C2241 VDD.n280 VSS 0.12909f
C2242 VDD.n281 VSS 0.17567f
C2243 VDD.n282 VSS 0.02156f
C2244 VDD.n283 VSS 0.12937f
C2245 VDD.n284 VSS 0.12937f
C2246 VDD.n285 VSS 0.05929f
C2247 VDD.t139 VSS 0.13909f
C2248 VDD.t101 VSS 0.13909f
C2249 VDD.n286 VSS 0.04836f
C2250 VDD.t137 VSS 0.13909f
C2251 VDD.t135 VSS 0.14158f
C2252 VDD.n287 VSS 0.04874f
C2253 VDD.n288 VSS 0.10421f
C2254 VDD.n289 VSS 0.14725f
C2255 VDD.n290 VSS 0.05929f
C2256 VDD.t285 VSS 0.18616f
C2257 VDD.t287 VSS 0.18612f
C2258 VDD.n291 VSS 0.10678f
C2259 VDD.n292 VSS 0.14498f
C2260 VDD.n293 VSS 0.08625f
C2261 VDD.n294 VSS 0.12937f
C2262 VDD.n295 VSS 0.12937f
C2263 VDD.n296 VSS 0.04851f
C2264 VDD.t125 VSS 0.13909f
C2265 VDD.t123 VSS 0.13909f
C2266 VDD.n297 VSS 0.04836f
C2267 VDD.t121 VSS 0.13909f
C2268 VDD.t119 VSS 0.14158f
C2269 VDD.n298 VSS 0.04874f
C2270 VDD.n299 VSS 0.10421f
C2271 VDD.n300 VSS 0.14294f
C2272 VDD.t95 VSS 0.18416f
C2273 VDD.t164 VSS 0.18416f
C2274 VDD.n301 VSS 0.04836f
C2275 VDD.t166 VSS 0.18416f
C2276 VDD.t72 VSS 0.18751f
C2277 VDD.n302 VSS 0.04874f
C2278 VDD.n303 VSS 0.07941f
C2279 VDD.n304 VSS 0.11599f
C2280 VDD.n305 VSS 0.04352f
C2281 VDD.t99 VSS 0.10401f
C2282 VDD.t97 VSS 0.10401f
C2283 VDD.n306 VSS 0.04874f
C2284 VDD.t105 VSS 0.10401f
C2285 VDD.t103 VSS 0.10401f
C2286 VDD.n307 VSS 0.04836f
C2287 VDD.n308 VSS 0.02451f
C2288 VDD.t109 VSS 0.10401f
C2289 VDD.t107 VSS 0.10401f
C2290 VDD.n309 VSS 0.04836f
C2291 VDD.n310 VSS 0.01388f
C2292 VDD.t113 VSS 0.10401f
C2293 VDD.t111 VSS 0.10401f
C2294 VDD.n311 VSS 0.04836f
C2295 VDD.n312 VSS 0.01388f
C2296 VDD.t117 VSS 0.10658f
C2297 VDD.t115 VSS 0.10401f
C2298 VDD.n313 VSS 0.04836f
C2299 VDD.n314 VSS 0.18864f
C2300 VDD.n315 VSS 0.13623f
C2301 VDD.t293 VSS 0.18283f
C2302 VDD.t295 VSS 0.18283f
C2303 VDD.n316 VSS 0.04836f
C2304 VDD.t189 VSS 0.18283f
C2305 VDD.t191 VSS 0.18616f
C2306 VDD.n317 VSS 0.04874f
C2307 VDD.n318 VSS 0.12901f
C2308 VDD.n319 VSS 0.19232f
C2309 VDD.n320 VSS 0.0539f
C2310 VDD.n321 VSS 0.12937f
C2311 VDD.n322 VSS 0.12937f
C2312 VDD.n323 VSS 0.11212f
C2313 VDD.n324 VSS 0.07654f
C2314 VDD.t83 VSS 0.12575f
C2315 VDD.t85 VSS 0.12798f
C2316 VDD.n325 VSS 0.04874f
C2317 VDD.t81 VSS 0.17558f
C2318 VDD.n326 VSS 0.13482f
C2319 VDD.n327 VSS 0.30034f
C2320 VDD.n328 VSS 0.13526f
C2321 VDD.n329 VSS 0.18446f
C2322 VDD.n330 VSS 0.14049f
C2323 VDD.n331 VSS 0.16475f
C2324 VDD.n332 VSS 3.09977f
C2325 VDD.n333 VSS 4.12141f
C2326 VDD.n334 VSS 0.06836f
C2327 VDD.n335 VSS 0.08453f
C2328 VDD.n336 VSS 0.08453f
C2329 VDD.n337 VSS 0.08086f
C2330 VDD.n338 VSS 3.01861f
C2331 VDD.t84 VSS 0.53904f
C2332 VDD.t82 VSS 0.43123f
C2333 VDD.t80 VSS 2.15615f
C2334 VDD.n339 VSS 4.78474f
C2335 VDD.n340 VSS 3.98888f
C2336 VDD.n341 VSS 0.08086f
C2337 VDD.n342 VSS 0.08453f
C2338 VDD.n343 VSS 0.08453f
C2339 VDD.n344 VSS 0.08453f
C2340 VDD.n345 VSS 0.08086f
C2341 VDD.n346 VSS 0.86246f
C2342 VDD.t71 VSS 0.43123f
C2343 VDD.t165 VSS 0.43123f
C2344 VDD.t163 VSS 0.43123f
C2345 VDD.t94 VSS 2.04834f
C2346 VDD.n347 VSS 2.04834f
C2347 VDD.t118 VSS 0.43123f
C2348 VDD.t120 VSS 0.43123f
C2349 VDD.t122 VSS 0.43123f
C2350 VDD.t124 VSS 1.50931f
C2351 VDD.n348 VSS 1.87393f
C2352 VDD.t92 VSS 0.53904f
C2353 VDD.n349 VSS 0.21562f
C2354 VDD.n350 VSS 0.08086f
C2355 VDD.n351 VSS 0.08453f
C2356 VDD.n352 VSS 0.08453f
C2357 VDD.n353 VSS 0.08453f
C2358 VDD.n354 VSS 0.08086f
C2359 VDD.n355 VSS 0.21562f
C2360 VDD.t284 VSS 0.53904f
C2361 VDD.n356 VSS 1.87393f
C2362 VDD.n357 VSS 0.2285f
C2363 VDD.n358 VSS 0.2285f
C2364 VDD.n359 VSS 0.36463f
C2365 VDD.t146 VSS 0.32342f
C2366 VDD.t152 VSS 0.43123f
C2367 VDD.t154 VSS 0.43123f
C2368 VDD.t156 VSS 0.43123f
C2369 VDD.t158 VSS 0.32342f
C2370 VDD.n360 VSS 0.86246f
C2371 VDD.t46 VSS 0.97027f
C2372 VDD.t44 VSS 0.43123f
C2373 VDD.t65 VSS 0.43123f
C2374 VDD.t63 VSS 1.50931f
C2375 VDD.n361 VSS 3.98888f
C2376 VDD.n362 VSS 0.08086f
C2377 VDD.n363 VSS 0.08453f
C2378 VDD.n364 VSS 0.08453f
C2379 VDD.n365 VSS 0.08453f
C2380 VDD.n366 VSS 0.08086f
C2381 VDD.n367 VSS 3.01861f
C2382 VDD.n368 VSS 3.77326f
C2383 VDD.n369 VSS 3.11046f
C2384 VDD.n370 VSS 4.12141f
C2385 VDD.n371 VSS 0.06836f
C2386 VDD.n372 VSS 3.70337f
C2387 VDD.n373 VSS 19.5026f
C2388 VDD.n374 VSS 12.0847f
C2389 E_SENSE_CLK.n0 VSS 0.48214f
C2390 E_SENSE_CLK.n1 VSS 0.08669f
C2391 E_SENSE_CLK.n2 VSS 0.08669f
C2392 E_SENSE_CLK.n3 VSS 0.08669f
C2393 E_SENSE_CLK.n4 VSS 0.08669f
C2394 E_SENSE_CLK.n5 VSS 0.08669f
C2395 E_SENSE_CLK.n6 VSS 0.08669f
C2396 E_SENSE_CLK.n7 VSS 0.25231f
C2397 E_SENSE_CLK.n8 VSS 0.18735f
C2398 E_SENSE_CLK.n9 VSS 0.18735f
C2399 E_SENSE_CLK.n10 VSS 0.18735f
C2400 E_SENSE_CLK.n11 VSS 0.18735f
C2401 E_SENSE_CLK.n12 VSS 0.18735f
C2402 E_SENSE_CLK.n13 VSS 0.18735f
C2403 E_SENSE_CLK.n14 VSS 0.18735f
C2404 E_SENSE_CLK.n15 VSS 0.37013f
C2405 E_SENSE_CLK.n16 VSS 0.12471f
C2406 E_SENSE_CLK.n17 VSS 0.13368f
C2407 E_SENSE_CLK.n18 VSS 0.13368f
C2408 E_SENSE_CLK.n19 VSS 0.13368f
C2409 E_SENSE_CLK.n20 VSS 0.13368f
C2410 E_SENSE_CLK.n21 VSS 0.13368f
C2411 E_SENSE_CLK.n22 VSS 0.13368f
C2412 E_SENSE_CLK.n23 VSS 0.13368f
C2413 E_SENSE_CLK.n24 VSS 0.13368f
C2414 E_SENSE_CLK.n25 VSS 0.12634f
C2415 E_SENSE_CLK.n26 VSS 0.32313f
C2416 E_SENSE_CLK.n27 VSS 3.59056f
C2417 E_SENSE_CLK.n28 VSS 0.24459f
C2418 E_SENSE_CLK.n29 VSS 0.12471f
C2419 E_SENSE_CLK.n30 VSS 0.13368f
C2420 E_SENSE_CLK.n31 VSS 0.13368f
C2421 E_SENSE_CLK.n32 VSS 0.12642f
C2422 E_SENSE_CLK.n33 VSS 1.7118f
C2423 E_SENSE_CLK.n34 VSS 5.33063f
C2424 E_SENSE_CLK.n35 VSS 0.46283f
C2425 E_SENSE_CLK.n36 VSS 0.08649f
C2426 E_SENSE_CLK.n37 VSS 0.13368f
C2427 E_SENSE_CLK.n38 VSS 0.18735f
C2428 E_SENSE_CLK.n39 VSS 0.08669f
C2429 E_SENSE_CLK.n40 VSS 0.08669f
C2430 E_SENSE_CLK.n41 VSS 0.25231f
C2431 E_SENSE_CLK.n42 VSS 0.37013f
C2432 E_SENSE_CLK.n43 VSS 0.12471f
C2433 E_SENSE_CLK.n44 VSS 0.13368f
C2434 E_SENSE_CLK.n45 VSS 0.13368f
C2435 E_SENSE_CLK.n46 VSS 0.13368f
C2436 E_SENSE_CLK.n47 VSS 0.18735f
C2437 E_SENSE_CLK.n48 VSS 0.18735f
C2438 E_SENSE_CLK.n49 VSS 0.18716f
C2439 E_SENSE_CLK.n50 VSS 0.13368f
C2440 E_SENSE_CLK.n51 VSS 0.13368f
C2441 E_SENSE_CLK.n52 VSS 0.12185f
C2442 E_SENSE_CLK.n53 VSS 0.20207f
C2443 E_SENSE_CLK.n54 VSS 3.08855f
C2444 E_SENSE_CLK.n55 VSS 2.11634f
C2445 E_SENSE_CLK.n56 VSS 0.14721f
C2446 E_SENSE_CLK.n57 VSS 0.25135f
C2447 E_SENSE_CLK.n58 VSS 0.14554f
C2448 E_SENSE_CLK.n59 VSS 0.15424f
C2449 E_SENSE_CLK.n60 VSS 0.15424f
C2450 E_SENSE_CLK.n61 VSS 0.15424f
C2451 E_SENSE_CLK.n62 VSS 0.06781f
C2452 E_SENSE_CLK.n63 VSS 0.28721f
C2453 E_SENSE_CLK.n64 VSS 0.92752f
C2454 E_SENSE_CLK.n65 VSS 0.24459f
C2455 E_SENSE_CLK.n66 VSS 0.12471f
C2456 E_SENSE_CLK.n67 VSS 0.13368f
C2457 E_SENSE_CLK.n68 VSS 0.13368f
C2458 E_SENSE_CLK.n69 VSS 0.12642f
C2459 E_SENSE_CLK.n70 VSS 1.7118f
C2460 E_SENSE_CLK.n71 VSS 3.57558f
C2461 E_SENSE_CLK.n72 VSS 0.39796f
C2462 E_SENSE_CLK.n73 VSS 0.08669f
C2463 E_SENSE_CLK.n74 VSS 0.13368f
C2464 E_SENSE_CLK.n75 VSS 0.18735f
C2465 E_SENSE_CLK.n76 VSS 0.13368f
C2466 E_SENSE_CLK.n77 VSS 0.08669f
C2467 E_SENSE_CLK.n78 VSS 0.08669f
C2468 E_SENSE_CLK.n79 VSS 0.13368f
C2469 E_SENSE_CLK.n80 VSS 0.37013f
C2470 E_SENSE_CLK.n81 VSS 0.13368f
C2471 E_SENSE_CLK.n82 VSS 0.12471f
C2472 E_SENSE_CLK.n83 VSS 0.25231f
C2473 E_SENSE_CLK.n84 VSS 0.13368f
C2474 E_SENSE_CLK.n85 VSS 0.18735f
C2475 E_SENSE_CLK.n86 VSS 0.18735f
C2476 E_SENSE_CLK.n87 VSS 0.18735f
C2477 E_SENSE_CLK.n88 VSS 0.13368f
C2478 E_SENSE_CLK.n89 VSS 0.08669f
C2479 E_SENSE_CLK.n90 VSS 0.08669f
C2480 E_SENSE_CLK.n91 VSS 0.08669f
C2481 E_SENSE_CLK.n92 VSS 0.13368f
C2482 E_SENSE_CLK.n93 VSS 0.18735f
C2483 E_SENSE_CLK.n94 VSS 0.18735f
C2484 E_SENSE_CLK.n95 VSS 0.18735f
C2485 E_SENSE_CLK.n96 VSS 0.13368f
C2486 E_SENSE_CLK.n97 VSS 0.12634f
C2487 E_SENSE_CLK.n98 VSS 0.23878f
C2488 E_SENSE_CLK.n99 VSS 3.09475f
C2489 E_SENSE_CLK.n100 VSS 4.35577f
C2490 O_SENSE_CLK.n0 VSS 0.48214f
C2491 O_SENSE_CLK.n1 VSS 0.08669f
C2492 O_SENSE_CLK.n2 VSS 0.13368f
C2493 O_SENSE_CLK.n3 VSS 0.18735f
C2494 O_SENSE_CLK.n4 VSS 0.13368f
C2495 O_SENSE_CLK.n5 VSS 0.08669f
C2496 O_SENSE_CLK.n6 VSS 0.08669f
C2497 O_SENSE_CLK.n7 VSS 0.13368f
C2498 O_SENSE_CLK.n8 VSS 0.37013f
C2499 O_SENSE_CLK.n9 VSS 0.13368f
C2500 O_SENSE_CLK.n10 VSS 0.12471f
C2501 O_SENSE_CLK.n11 VSS 0.25231f
C2502 O_SENSE_CLK.n12 VSS 0.13368f
C2503 O_SENSE_CLK.n13 VSS 0.18735f
C2504 O_SENSE_CLK.n14 VSS 0.18735f
C2505 O_SENSE_CLK.n15 VSS 0.18735f
C2506 O_SENSE_CLK.n16 VSS 0.13368f
C2507 O_SENSE_CLK.n17 VSS 0.08669f
C2508 O_SENSE_CLK.n18 VSS 0.08669f
C2509 O_SENSE_CLK.n19 VSS 0.08669f
C2510 O_SENSE_CLK.n20 VSS 0.13368f
C2511 O_SENSE_CLK.n21 VSS 0.18735f
C2512 O_SENSE_CLK.n22 VSS 0.18735f
C2513 O_SENSE_CLK.n23 VSS 0.18735f
C2514 O_SENSE_CLK.n24 VSS 0.13368f
C2515 O_SENSE_CLK.n25 VSS 0.12634f
C2516 O_SENSE_CLK.n26 VSS 0.32313f
C2517 O_SENSE_CLK.n27 VSS 3.59056f
C2518 O_SENSE_CLK.n28 VSS 0.12642f
C2519 O_SENSE_CLK.n29 VSS 0.12471f
C2520 O_SENSE_CLK.n30 VSS 0.13368f
C2521 O_SENSE_CLK.n31 VSS 0.13368f
C2522 O_SENSE_CLK.n32 VSS 0.24459f
C2523 O_SENSE_CLK.n33 VSS 1.7118f
C2524 O_SENSE_CLK.n34 VSS 5.33063f
C2525 O_SENSE_CLK.n35 VSS 0.46283f
C2526 O_SENSE_CLK.n36 VSS 0.12185f
C2527 O_SENSE_CLK.n37 VSS 0.08669f
C2528 O_SENSE_CLK.n38 VSS 0.13368f
C2529 O_SENSE_CLK.n39 VSS 0.08669f
C2530 O_SENSE_CLK.n40 VSS 0.13368f
C2531 O_SENSE_CLK.n41 VSS 0.18716f
C2532 O_SENSE_CLK.n42 VSS 0.18735f
C2533 O_SENSE_CLK.n43 VSS 0.18735f
C2534 O_SENSE_CLK.n44 VSS 0.18735f
C2535 O_SENSE_CLK.n45 VSS 0.37013f
C2536 O_SENSE_CLK.n46 VSS 0.12471f
C2537 O_SENSE_CLK.n47 VSS 0.25231f
C2538 O_SENSE_CLK.n48 VSS 0.13368f
C2539 O_SENSE_CLK.n49 VSS 0.13368f
C2540 O_SENSE_CLK.n50 VSS 0.13368f
C2541 O_SENSE_CLK.n51 VSS 0.13368f
C2542 O_SENSE_CLK.n52 VSS 0.08649f
C2543 O_SENSE_CLK.n53 VSS 0.20207f
C2544 O_SENSE_CLK.n54 VSS 3.08855f
C2545 O_SENSE_CLK.n55 VSS 2.11634f
C2546 O_SENSE_CLK.n56 VSS 0.06781f
C2547 O_SENSE_CLK.n57 VSS 0.15424f
C2548 O_SENSE_CLK.n58 VSS 0.14554f
C2549 O_SENSE_CLK.n59 VSS 0.25135f
C2550 O_SENSE_CLK.n60 VSS 0.15424f
C2551 O_SENSE_CLK.n61 VSS 0.15424f
C2552 O_SENSE_CLK.n62 VSS 0.14721f
C2553 O_SENSE_CLK.n63 VSS 0.28721f
C2554 O_SENSE_CLK.n64 VSS 0.92752f
C2555 O_SENSE_CLK.n65 VSS 0.12642f
C2556 O_SENSE_CLK.n66 VSS 0.12471f
C2557 O_SENSE_CLK.n67 VSS 0.13368f
C2558 O_SENSE_CLK.n68 VSS 0.13368f
C2559 O_SENSE_CLK.n69 VSS 0.24459f
C2560 O_SENSE_CLK.n70 VSS 1.7118f
C2561 O_SENSE_CLK.n71 VSS 3.57558f
C2562 O_SENSE_CLK.n72 VSS 0.39796f
C2563 O_SENSE_CLK.n73 VSS 0.08669f
C2564 O_SENSE_CLK.n74 VSS 0.08669f
C2565 O_SENSE_CLK.n75 VSS 0.08669f
C2566 O_SENSE_CLK.n76 VSS 0.08669f
C2567 O_SENSE_CLK.n77 VSS 0.08669f
C2568 O_SENSE_CLK.n78 VSS 0.08669f
C2569 O_SENSE_CLK.n79 VSS 0.25231f
C2570 O_SENSE_CLK.n80 VSS 0.18735f
C2571 O_SENSE_CLK.n81 VSS 0.18735f
C2572 O_SENSE_CLK.n82 VSS 0.18735f
C2573 O_SENSE_CLK.n83 VSS 0.18735f
C2574 O_SENSE_CLK.n84 VSS 0.18735f
C2575 O_SENSE_CLK.n85 VSS 0.18735f
C2576 O_SENSE_CLK.n86 VSS 0.18735f
C2577 O_SENSE_CLK.n87 VSS 0.37013f
C2578 O_SENSE_CLK.n88 VSS 0.12471f
C2579 O_SENSE_CLK.n89 VSS 0.13368f
C2580 O_SENSE_CLK.n90 VSS 0.13368f
C2581 O_SENSE_CLK.n91 VSS 0.13368f
C2582 O_SENSE_CLK.n92 VSS 0.13368f
C2583 O_SENSE_CLK.n93 VSS 0.13368f
C2584 O_SENSE_CLK.n94 VSS 0.13368f
C2585 O_SENSE_CLK.n95 VSS 0.13368f
C2586 O_SENSE_CLK.n96 VSS 0.13368f
C2587 O_SENSE_CLK.n97 VSS 0.12634f
C2588 O_SENSE_CLK.n98 VSS 0.23878f
C2589 O_SENSE_CLK.n99 VSS 3.09475f
C2590 O_SENSE_CLK.n100 VSS 4.35577f
C2591 FE_E_P.t6 VSS 0.83944f
C2592 FE_E_P.t4 VSS 0.84493f
C2593 FE_E_P.t2 VSS 0.23629f
C2594 FE_E_P.t3 VSS 0.23629f
C2595 FE_E_P.n0 VSS 0.58043f
C2596 FE_E_P.n1 VSS 0.2941f
C2597 FE_E_P.n2 VSS 0.44015f
C2598 FE_E_P.t1 VSS 0.84545f
C2599 FE_E_P.t5 VSS 0.23629f
C2600 FE_E_P.t0 VSS 0.23629f
C2601 FE_E_P.n3 VSS 0.58508f
C2602 FE_E_P.n4 VSS 0.50614f
C2603 FE_E_P.n5 VSS 1.34972f
C2604 FE_E_N.t0 VSS 0.81446f
C2605 FE_E_N.t3 VSS 0.22562f
C2606 FE_E_N.t4 VSS 0.22562f
C2607 FE_E_N.n0 VSS 0.56561f
C2608 FE_E_N.n1 VSS 0.52821f
C2609 FE_E_N.t5 VSS 0.8087f
C2610 FE_E_N.t2 VSS 0.81396f
C2611 FE_E_N.t6 VSS 0.22562f
C2612 FE_E_N.t1 VSS 0.22562f
C2613 FE_E_N.n2 VSS 0.56112f
C2614 FE_E_N.n3 VSS 0.28431f
C2615 FE_E_N.n4 VSS 0.38673f
C2616 FE_E_N.n5 VSS 1.28652f
C2617 FE_O_P.t4 VSS 0.22562f
C2618 FE_O_P.t5 VSS 0.22562f
C2619 FE_O_P.n0 VSS 0.56561f
C2620 FE_O_P.t6 VSS 0.81446f
C2621 FE_O_P.n1 VSS 0.52821f
C2622 FE_O_P.t0 VSS 0.81396f
C2623 FE_O_P.t1 VSS 0.22562f
C2624 FE_O_P.t2 VSS 0.22562f
C2625 FE_O_P.n2 VSS 0.56112f
C2626 FE_O_P.n3 VSS 0.28431f
C2627 FE_O_P.t3 VSS 0.8087f
C2628 FE_O_P.n4 VSS 0.38673f
C2629 FE_O_P.n5 VSS 1.28652f
C2630 FE_O_N.t0 VSS 0.84493f
C2631 FE_O_N.t1 VSS 0.23629f
C2632 FE_O_N.t2 VSS 0.23629f
C2633 FE_O_N.n0 VSS 0.58043f
C2634 FE_O_N.n1 VSS 0.2941f
C2635 FE_O_N.t3 VSS 0.83944f
C2636 FE_O_N.n2 VSS 0.44015f
C2637 FE_O_N.t4 VSS 0.23629f
C2638 FE_O_N.t5 VSS 0.23629f
C2639 FE_O_N.n3 VSS 0.58508f
C2640 FE_O_N.t6 VSS 0.84545f
C2641 FE_O_N.n4 VSS 0.50614f
C2642 FE_O_N.n5 VSS 1.34972f
C2643 RX_RAWP.n0 VSS 0.26582f
C2644 RX_RAWP.n1 VSS 0.06998f
C2645 RX_RAWP.n2 VSS 0.04979f
C2646 RX_RAWP.n3 VSS 0.07678f
C2647 RX_RAWP.n4 VSS 0.04979f
C2648 RX_RAWP.n5 VSS 0.07678f
C2649 RX_RAWP.n6 VSS 0.10749f
C2650 RX_RAWP.n7 VSS 0.1076f
C2651 RX_RAWP.n8 VSS 0.1076f
C2652 RX_RAWP.n9 VSS 0.1076f
C2653 RX_RAWP.n10 VSS 0.21258f
C2654 RX_RAWP.n11 VSS 0.07163f
C2655 RX_RAWP.n12 VSS 0.14491f
C2656 RX_RAWP.n13 VSS 0.07678f
C2657 RX_RAWP.n14 VSS 0.07678f
C2658 RX_RAWP.n15 VSS 0.07678f
C2659 RX_RAWP.n16 VSS 0.07678f
C2660 RX_RAWP.n17 VSS 0.04967f
C2661 RX_RAWP.n18 VSS 0.11605f
C2662 RX_RAWP.n19 VSS 3.66196f
C2663 RX_RAWP.n20 VSS 0.26582f
C2664 RX_RAWP.n21 VSS 0.06998f
C2665 RX_RAWP.n22 VSS 0.04979f
C2666 RX_RAWP.n23 VSS 0.07678f
C2667 RX_RAWP.n24 VSS 0.07678f
C2668 RX_RAWP.n25 VSS 0.1076f
C2669 RX_RAWP.n26 VSS 0.04979f
C2670 RX_RAWP.n27 VSS 0.14491f
C2671 RX_RAWP.n28 VSS 0.21258f
C2672 RX_RAWP.n29 VSS 0.07163f
C2673 RX_RAWP.n30 VSS 0.07678f
C2674 RX_RAWP.n31 VSS 0.07678f
C2675 RX_RAWP.n32 VSS 0.07678f
C2676 RX_RAWP.n33 VSS 0.1076f
C2677 RX_RAWP.n34 VSS 0.1076f
C2678 RX_RAWP.n35 VSS 0.10749f
C2679 RX_RAWP.n36 VSS 0.07678f
C2680 RX_RAWP.n37 VSS 0.04967f
C2681 RX_RAWP.n38 VSS 0.11605f
C2682 RX_RAWP.n39 VSS 3.82501f
C2683 RX_RAWP.n40 VSS 11.7375f
C2684 RX_RAWP.t2 VSS 0.14769f
C2685 RX_RAWP.t0 VSS 0.41342f
C2686 RX_RAWP.t1 VSS 0.3161f
C2687 RX_RAWP.t3 VSS 0.3162f
C2688 RX_RAWP.n41 VSS 0.63962f
C2689 RX_RAWP.n42 VSS 2.10961f
C2690 RX_RAWP.n43 VSS 0.89266f
C2691 RX_RAWN.n0 VSS 0.26671f
C2692 RX_RAWN.n1 VSS 0.04984f
C2693 RX_RAWN.n2 VSS 0.07703f
C2694 RX_RAWN.n3 VSS 0.10796f
C2695 RX_RAWN.n4 VSS 0.04995f
C2696 RX_RAWN.n5 VSS 0.04995f
C2697 RX_RAWN.n6 VSS 0.1454f
C2698 RX_RAWN.n7 VSS 0.21329f
C2699 RX_RAWN.n8 VSS 0.07187f
C2700 RX_RAWN.n9 VSS 0.07703f
C2701 RX_RAWN.n10 VSS 0.07703f
C2702 RX_RAWN.n11 VSS 0.07703f
C2703 RX_RAWN.n12 VSS 0.10796f
C2704 RX_RAWN.n13 VSS 0.10796f
C2705 RX_RAWN.n14 VSS 0.10785f
C2706 RX_RAWN.n15 VSS 0.07703f
C2707 RX_RAWN.n16 VSS 0.07703f
C2708 RX_RAWN.n17 VSS 0.07022f
C2709 RX_RAWN.n18 VSS 0.11644f
C2710 RX_RAWN.n19 VSS 4.13692f
C2711 RX_RAWN.n20 VSS 0.26671f
C2712 RX_RAWN.n21 VSS 0.04984f
C2713 RX_RAWN.n22 VSS 0.07703f
C2714 RX_RAWN.n23 VSS 0.10796f
C2715 RX_RAWN.n24 VSS 0.04995f
C2716 RX_RAWN.n25 VSS 0.04995f
C2717 RX_RAWN.n26 VSS 0.1454f
C2718 RX_RAWN.n27 VSS 0.21329f
C2719 RX_RAWN.n28 VSS 0.07187f
C2720 RX_RAWN.n29 VSS 0.07703f
C2721 RX_RAWN.n30 VSS 0.07703f
C2722 RX_RAWN.n31 VSS 0.07703f
C2723 RX_RAWN.n32 VSS 0.10796f
C2724 RX_RAWN.n33 VSS 0.10796f
C2725 RX_RAWN.n34 VSS 0.10785f
C2726 RX_RAWN.n35 VSS 0.07703f
C2727 RX_RAWN.n36 VSS 0.07703f
C2728 RX_RAWN.n37 VSS 0.07022f
C2729 RX_RAWN.n38 VSS 0.11644f
C2730 RX_RAWN.n39 VSS 3.80502f
C2731 RX_RAWN.n40 VSS 10.8663f
C2732 RX_RAWN.t2 VSS 0.14192f
C2733 RX_RAWN.t0 VSS 0.42837f
C2734 RX_RAWN.t3 VSS 0.31678f
C2735 RX_RAWN.t1 VSS 0.31667f
C2736 RX_RAWN.n41 VSS 0.64176f
C2737 RX_RAWN.n42 VSS 2.25415f
C2738 RX_RAWN.n43 VSS 0.99967f
C2739 E_SENSE_BOOST.n0 VSS 0.12585f
C2740 E_SENSE_BOOST.n1 VSS 0.04212f
C2741 E_SENSE_BOOST.n2 VSS 0.07511f
C2742 E_SENSE_BOOST.n3 VSS 0.10146f
C2743 E_SENSE_BOOST.n4 VSS 0.04222f
C2744 E_SENSE_BOOST.n5 VSS 0.04222f
C2745 E_SENSE_BOOST.n6 VSS 0.04222f
C2746 E_SENSE_BOOST.n7 VSS 0.04222f
C2747 E_SENSE_BOOST.n8 VSS 0.04222f
C2748 E_SENSE_BOOST.n9 VSS 0.12288f
C2749 E_SENSE_BOOST.n10 VSS 0.10146f
C2750 E_SENSE_BOOST.n11 VSS 0.10146f
C2751 E_SENSE_BOOST.n12 VSS 0.10146f
C2752 E_SENSE_BOOST.n13 VSS 0.20071f
C2753 E_SENSE_BOOST.n14 VSS 0.07088f
C2754 E_SENSE_BOOST.n15 VSS 0.07511f
C2755 E_SENSE_BOOST.n16 VSS 0.07511f
C2756 E_SENSE_BOOST.n17 VSS 0.07511f
C2757 E_SENSE_BOOST.n18 VSS 0.07511f
C2758 E_SENSE_BOOST.n19 VSS 0.07511f
C2759 E_SENSE_BOOST.n20 VSS 0.07511f
C2760 E_SENSE_BOOST.n21 VSS 0.10146f
C2761 E_SENSE_BOOST.n22 VSS 0.10146f
C2762 E_SENSE_BOOST.n23 VSS 0.10137f
C2763 E_SENSE_BOOST.n24 VSS 0.07511f
C2764 E_SENSE_BOOST.n25 VSS 0.07511f
C2765 E_SENSE_BOOST.n26 VSS 0.04222f
C2766 E_SENSE_BOOST.n27 VSS 0.07511f
C2767 E_SENSE_BOOST.n28 VSS 0.10146f
C2768 E_SENSE_BOOST.n29 VSS 0.04222f
C2769 E_SENSE_BOOST.n30 VSS 0.04222f
C2770 E_SENSE_BOOST.n31 VSS 0.04222f
C2771 E_SENSE_BOOST.n32 VSS 0.04222f
C2772 E_SENSE_BOOST.n33 VSS 0.04222f
C2773 E_SENSE_BOOST.n34 VSS 0.04222f
C2774 E_SENSE_BOOST.n35 VSS 0.04222f
C2775 E_SENSE_BOOST.n36 VSS 0.04222f
C2776 E_SENSE_BOOST.n37 VSS 0.04222f
C2777 E_SENSE_BOOST.n38 VSS 0.12288f
C2778 E_SENSE_BOOST.n39 VSS 0.10146f
C2779 E_SENSE_BOOST.n40 VSS 0.10146f
C2780 E_SENSE_BOOST.n41 VSS 0.10146f
C2781 E_SENSE_BOOST.n42 VSS 0.10146f
C2782 E_SENSE_BOOST.n43 VSS 0.10146f
C2783 E_SENSE_BOOST.n44 VSS 0.10146f
C2784 E_SENSE_BOOST.n45 VSS 0.10146f
C2785 E_SENSE_BOOST.n46 VSS 0.10146f
C2786 E_SENSE_BOOST.n47 VSS 0.20071f
C2787 E_SENSE_BOOST.n48 VSS 0.07088f
C2788 E_SENSE_BOOST.n49 VSS 0.07511f
C2789 E_SENSE_BOOST.n50 VSS 0.07511f
C2790 E_SENSE_BOOST.n51 VSS 0.07511f
C2791 E_SENSE_BOOST.n52 VSS 0.07511f
C2792 E_SENSE_BOOST.n53 VSS 0.07511f
C2793 E_SENSE_BOOST.n54 VSS 0.07511f
C2794 E_SENSE_BOOST.n55 VSS 0.07511f
C2795 E_SENSE_BOOST.n56 VSS 0.07511f
C2796 E_SENSE_BOOST.n57 VSS 0.07511f
C2797 E_SENSE_BOOST.n58 VSS 0.07511f
C2798 E_SENSE_BOOST.n59 VSS 0.07511f
C2799 E_SENSE_BOOST.n60 VSS 0.10146f
C2800 E_SENSE_BOOST.n61 VSS 0.10146f
C2801 E_SENSE_BOOST.n62 VSS 0.10137f
C2802 E_SENSE_BOOST.n63 VSS 0.07511f
C2803 E_SENSE_BOOST.n64 VSS 0.04212f
C2804 E_SENSE_BOOST.n65 VSS 0.07607f
C2805 E_SENSE_BOOST.n66 VSS 2.29248f
C2806 O_SENSE_BOOST.n0 VSS 0.12585f
C2807 O_SENSE_BOOST.n1 VSS 0.04212f
C2808 O_SENSE_BOOST.n2 VSS 0.07511f
C2809 O_SENSE_BOOST.n3 VSS 0.10146f
C2810 O_SENSE_BOOST.n4 VSS 0.04222f
C2811 O_SENSE_BOOST.n5 VSS 0.04222f
C2812 O_SENSE_BOOST.n6 VSS 0.04222f
C2813 O_SENSE_BOOST.n7 VSS 0.04222f
C2814 O_SENSE_BOOST.n8 VSS 0.04222f
C2815 O_SENSE_BOOST.n9 VSS 0.04222f
C2816 O_SENSE_BOOST.n10 VSS 0.04222f
C2817 O_SENSE_BOOST.n11 VSS 0.04222f
C2818 O_SENSE_BOOST.n12 VSS 0.04222f
C2819 O_SENSE_BOOST.n13 VSS 0.04222f
C2820 O_SENSE_BOOST.n14 VSS 0.12288f
C2821 O_SENSE_BOOST.n15 VSS 0.10146f
C2822 O_SENSE_BOOST.n16 VSS 0.10146f
C2823 O_SENSE_BOOST.n17 VSS 0.10146f
C2824 O_SENSE_BOOST.n18 VSS 0.10146f
C2825 O_SENSE_BOOST.n19 VSS 0.10146f
C2826 O_SENSE_BOOST.n20 VSS 0.10146f
C2827 O_SENSE_BOOST.n21 VSS 0.10146f
C2828 O_SENSE_BOOST.n22 VSS 0.10146f
C2829 O_SENSE_BOOST.n23 VSS 0.20071f
C2830 O_SENSE_BOOST.n24 VSS 0.07088f
C2831 O_SENSE_BOOST.n25 VSS 0.07511f
C2832 O_SENSE_BOOST.n26 VSS 0.07511f
C2833 O_SENSE_BOOST.n27 VSS 0.07511f
C2834 O_SENSE_BOOST.n28 VSS 0.07511f
C2835 O_SENSE_BOOST.n29 VSS 0.07511f
C2836 O_SENSE_BOOST.n30 VSS 0.07511f
C2837 O_SENSE_BOOST.n31 VSS 0.07511f
C2838 O_SENSE_BOOST.n32 VSS 0.07511f
C2839 O_SENSE_BOOST.n33 VSS 0.07511f
C2840 O_SENSE_BOOST.n34 VSS 0.07511f
C2841 O_SENSE_BOOST.n35 VSS 0.07511f
C2842 O_SENSE_BOOST.n36 VSS 0.10146f
C2843 O_SENSE_BOOST.n37 VSS 0.10146f
C2844 O_SENSE_BOOST.n38 VSS 0.10137f
C2845 O_SENSE_BOOST.n39 VSS 0.07511f
C2846 O_SENSE_BOOST.n40 VSS 0.07511f
C2847 O_SENSE_BOOST.n41 VSS 0.04222f
C2848 O_SENSE_BOOST.n42 VSS 0.07511f
C2849 O_SENSE_BOOST.n43 VSS 0.10146f
C2850 O_SENSE_BOOST.n44 VSS 0.04222f
C2851 O_SENSE_BOOST.n45 VSS 0.04222f
C2852 O_SENSE_BOOST.n46 VSS 0.04222f
C2853 O_SENSE_BOOST.n47 VSS 0.04222f
C2854 O_SENSE_BOOST.n48 VSS 0.12288f
C2855 O_SENSE_BOOST.n49 VSS 0.10146f
C2856 O_SENSE_BOOST.n50 VSS 0.10146f
C2857 O_SENSE_BOOST.n51 VSS 0.10146f
C2858 O_SENSE_BOOST.n52 VSS 0.20071f
C2859 O_SENSE_BOOST.n53 VSS 0.07088f
C2860 O_SENSE_BOOST.n54 VSS 0.07511f
C2861 O_SENSE_BOOST.n55 VSS 0.07511f
C2862 O_SENSE_BOOST.n56 VSS 0.07511f
C2863 O_SENSE_BOOST.n57 VSS 0.07511f
C2864 O_SENSE_BOOST.n58 VSS 0.07511f
C2865 O_SENSE_BOOST.n59 VSS 0.07511f
C2866 O_SENSE_BOOST.n60 VSS 0.10146f
C2867 O_SENSE_BOOST.n61 VSS 0.10146f
C2868 O_SENSE_BOOST.n62 VSS 0.10137f
C2869 O_SENSE_BOOST.n63 VSS 0.07511f
C2870 O_SENSE_BOOST.n64 VSS 0.04212f
C2871 O_SENSE_BOOST.n65 VSS 0.07607f
C2872 O_SENSE_BOOST.n66 VSS 2.29248f
C2873 RX_BW_EN_N.n0 VSS 2.42173f
C2874 RX_BW_EN_N.n1 VSS 2.35569f
C2875 VTHP.n0 VSS 0.29419f
C2876 VTHN.n0 VSS 0.29419f
C2877 RX_BIAS.n0 VSS 0.02779f
C2878 RX_BIAS.n1 VSS 0.02951f
C2879 RX_BIAS.n2 VSS 0.02951f
C2880 RX_BIAS.n3 VSS 0.02951f
C2881 RX_BIAS.n4 VSS 0.02779f
C2882 RX_BIAS.n5 VSS 0.11903f
C2883 RX_BIAS.n6 VSS 0.01107f
C2884 RX_BIAS.n7 VSS 0.01376f
C2885 RX_BIAS.n8 VSS 0.01376f
C2886 RX_BIAS.n9 VSS 0.01107f
C2887 RX_BIAS.n10 VSS 0.27482f
C2888 RX_BIAS.n11 VSS 0.02779f
C2889 RX_BIAS.n12 VSS 0.02951f
C2890 RX_BIAS.n13 VSS 0.02951f
C2891 RX_BIAS.n14 VSS 0.02951f
C2892 RX_BIAS.n15 VSS 0.02779f
C2893 RX_BIAS.n16 VSS 0.10781f
C2894 RX_BIAS.n17 VSS 0.72566f
C2895 RX_BIAS.n18 VSS 0.71306f
C2896 RXP.t5 VSS 0.17679f
C2897 RXP.n0 VSS 0.53688f
C2898 RXP.n1 VSS 2.22357f
C2899 RXP.t3 VSS 0.03579f
C2900 RXP.t6 VSS 0.03579f
C2901 RXP.t1 VSS 0.03579f
C2902 RXP.t4 VSS 0.03579f
C2903 RXP.t0 VSS 0.03579f
C2904 RXP.t7 VSS 0.03521f
C2905 RXP.t2 VSS 0.05232f
C2906 RXP.n2 VSS 0.77427f
C2907 RXP.n3 VSS 0.46432f
C2908 RXP.n4 VSS 0.46432f
C2909 RXP.n5 VSS 0.46432f
C2910 RXP.n6 VSS 0.46432f
C2911 RXP.n7 VSS 0.42573f
C2912 RXN.t6 VSS 0.07015f
C2913 RXN.n0 VSS 0.21303f
C2914 RXN.n1 VSS 0.88229f
C2915 RXN.t5 VSS 0.0142f
C2916 RXN.t2 VSS 0.0142f
C2917 RXN.t3 VSS 0.0142f
C2918 RXN.t7 VSS 0.0142f
C2919 RXN.t0 VSS 0.0142f
C2920 RXN.t1 VSS 0.01397f
C2921 RXN.t4 VSS 0.02076f
C2922 RXN.n2 VSS 0.30723f
C2923 RXN.n3 VSS 0.18424f
C2924 RXN.n4 VSS 0.18424f
C2925 RXN.n5 VSS 0.18424f
C2926 RXN.n6 VSS 0.18424f
C2927 RXN.n7 VSS 0.16893f
C2928 TERM_EN6_N.n0 VSS 0.40332f
C2929 TERM_EN6_N.n1 VSS 1.74029f
C2930 TERM_EN6_N.n2 VSS 0.71327f
C2931 TERM_EN5_N.n0 VSS 0.41634f
C2932 TERM_EN5_N.n1 VSS 1.79643f
C2933 TERM_EN5_N.n2 VSS 0.73628f
C2934 TERM_EN4_N.n0 VSS 0.41634f
C2935 TERM_EN4_N.n1 VSS 1.79643f
C2936 TERM_EN4_N.n2 VSS 0.73628f
C2937 TERM_EN3_N.n0 VSS 0.41634f
C2938 TERM_EN3_N.n1 VSS 1.79643f
C2939 TERM_EN3_N.n2 VSS 0.73628f
C2940 TERM_EN2_N.n0 VSS 0.41634f
C2941 TERM_EN2_N.n1 VSS 1.79643f
C2942 TERM_EN2_N.n2 VSS 0.73628f
C2943 TERM_EN1_N.n0 VSS 0.41296f
C2944 TERM_EN1_N.n1 VSS 1.78189f
C2945 TERM_EN1_N.n2 VSS 0.73031f
C2946 TERM_EN0_N.n0 VSS 0.38663f
C2947 TERM_EN0_N.n1 VSS 1.66825f
C2948 TERM_EN0_N.n2 VSS 0.68374f
.ends
