* PEX produced on Sun Aug 23 11:37:14 AM CEST 2026 using /foss/tools/sak/sak-pex.sh with m=3 and s=1 (extresist threshold=0 mOhm, minres=1 mOhm, mindelay=0 ps)
* NGSPICE file created from lane_rx_spine_pex.ext - technology: gf180mcuD

.subckt lane_rx_spine_pex RXP RXN VTHP VTHN RX_BIAS RX_BW_EN_N REST_BIAS SAMP_CLK_P
+ SAMP_CLK_N SAMP_BIAS VDD VSS RX_RAWP RX_RAWN RX_RESTP RX_RESTN EVEN_P EVEN_N ODD_P
+ ODD_N
X0 a_12148_44200.t0 ODD_N.t6 ODD_P.t0 VSS.t1 nfet_03v3 ad=1.56p pd=6.52u as=2.64p ps=12.88u w=6u l=0.28u
X1 VSS.t95 RX_BIAS.t4 a_2148_n500.t4 VSS.t94 nfet_03v3 ad=2.6p pd=10.52u as=4.4p ps=20.88u w=10u l=0.28u
X2 EVEN_P.t4 RX_RESTN.t5 a_948_44200.t5 VSS.t71 nfet_03v3 ad=2.64p pd=12.88u as=1.56p ps=6.52u w=6u l=0.28u
X3 RX_RESTN.t0 a_600_22678.t3 a_n852_28800.t0 VSS.t4 nfet_03v3 ad=4.4p pd=20.88u as=2.6p ps=10.52u w=10u l=0.28u
X4 a_n5052_2600.t3 VTHN.t1 a_n3600_5641.t4 VSS.t67 nfet_03v3 ad=0.52p pd=2.52u as=0.88p ps=4.88u w=2u l=0.28u
X5 VSS.t83 RX_BIAS.t13 a_n5052_2600.t4 VSS.t82 nfet_03v3 ad=0.52p pd=2.52u as=0.88p ps=4.88u w=2u l=0.28u
X6 a_2148_n500.t0 a_n6572_3500.t7 RX_RAWP.t1 VSS.t3 nfet_03v3 ad=1.3p pd=5.52u as=2.2p ps=10.88u w=5u l=0.28u
X7 a_600_22678.t2 RX_RAWN.t4 a_n852_19400.t1 VSS.t4 nfet_03v3 ad=4.4p pd=20.88u as=2.6p ps=10.52u w=10u l=0.28u
X8 a_n852_19400.t5 REST_BIAS.t0 VSS.t29 VSS.t23 nfet_03v3 ad=5.28p pd=24.88u as=3.12p ps=12.52u w=12u l=0.28u
X9 a_n5052_2600.t5 RX_BIAS.t12 VSS.t85 VSS.t84 nfet_03v3 ad=0.52p pd=2.52u as=0.52p ps=2.52u w=2u l=0.28u
X10 a_n852_28800.t6 REST_BIAS.t4 VSS.t24 VSS.t23 nfet_03v3 ad=5.28p pd=24.88u as=3.12p ps=12.52u w=12u l=0.28u
X11 a_10548_44200.t3 SAMP_CLK_N.t0 a_11748_41600.t7 VSS.t66 nfet_03v3 ad=3.52p pd=16.88u as=2.08p ps=8.52u w=8u l=0.28u
X12 RX_RAWP.t0 RX_BW_EN_N.t1 a_484_3500.t0 VDD.t3 pfet_03v3 ad=2.2p pd=10.88u as=2.2p ps=10.88u w=5u l=0.28u
X13 a_n5052_n1000.t5 RX_BIAS.t8 VSS.t89 VSS.t88 nfet_03v3 ad=2.6p pd=10.52u as=2.6p ps=10.52u w=10u l=0.28u
X14 EVEN_N.t3 RX_RESTP.t5 a_948_44200.t3 VSS.t51 nfet_03v3 ad=2.64p pd=12.88u as=1.56p ps=6.52u w=6u l=0.28u
X15 a_n1900_5958.t1 RX_BW_EN_N.t2 a_n3600_5641.t0 VDD.t2 pfet_03v3 ad=2.2p pd=10.88u as=2.2p ps=10.88u w=5u l=0.28u
X16 RX_RAWN.t2 a_n3600_5641.t6 a_2148_n500.t2 VSS.t10 nfet_03v3 ad=2.2p pd=10.88u as=1.3p ps=5.52u w=5u l=0.28u
X17 VDD.t11 ODD_P.t2 VSS.t56 ppolyf_u r_width=2u r_length=5u
X18 ODD_N.t1 ODD_P.t5 a_12148_44200.t3 VSS.t13 nfet_03v3 ad=2.64p pd=12.88u as=1.56p ps=6.52u w=6u l=0.28u
X19 a_n6572_3500.t0 RX_BW_EN_N.t3 a_n6716_3500.t0 VDD.t1 pfet_03v3 ad=2.2p pd=10.88u as=2.2p ps=10.88u w=5u l=0.28u
X20 VSS.t101 RX_BIAS.t2 a_2148_n500.t6 VSS.t100 nfet_03v3 ad=2.6p pd=10.52u as=2.6p ps=10.52u w=10u l=0.28u
X21 a_n852_28800.t7 a_600_22678.t4 RX_RESTN.t1 VSS.t14 nfet_03v3 ad=2.6p pd=10.52u as=4.4p ps=20.88u w=10u l=0.28u
X22 a_2548_44200.t5 SAMP_CLK_N.t2 a_2148_41600.t6 VSS.t64 nfet_03v3 ad=3.52p pd=16.88u as=2.08p ps=8.52u w=8u l=0.28u
X23 a_11748_41600.t3 SAMP_BIAS.t2 VSS.t45 VSS.t44 nfet_03v3 ad=2.6p pd=10.52u as=2.6p ps=10.52u w=10u l=0.28u
X24 a_n852_19400.t0 RX_RAWN.t5 a_600_22678.t1 VSS.t14 nfet_03v3 ad=2.6p pd=10.52u as=4.4p ps=20.88u w=10u l=0.28u
X25 a_n3600_5641.t5 VTHN.t0 a_n5052_2600.t2 VSS.t68 nfet_03v3 ad=0.88p pd=4.88u as=0.52p ps=2.52u w=2u l=0.28u
X26 a_n5052_2600.t7 RX_BIAS.t10 VSS.t81 VSS.t80 nfet_03v3 ad=0.88p pd=4.88u as=0.52p ps=2.52u w=2u l=0.28u
X27 a_n6572_3500.t5 RXP.t0 a_n5052_n1000.t2 VSS.t75 nfet_03v3 ad=4.4p pd=20.88u as=2.6p ps=10.52u w=10u l=0.28u
X28 a_11748_41600.t6 SAMP_CLK_N.t1 a_10548_44200.t2 VSS.t65 nfet_03v3 ad=2.08p pd=8.52u as=3.52p ps=16.88u w=8u l=0.28u
X29 VSS.t21 REST_BIAS.t3 a_n852_19400.t2 VSS.t20 nfet_03v3 ad=3.12p pd=12.52u as=5.28p ps=24.88u w=12u l=0.28u
X30 VDD.t19 RX_RAWN.t3 VSS.t77 ppolyf_u r_width=2u r_length=3.43u
X31 VSS.t105 RX_BIAS.t0 a_2148_n500.t8 VSS.t104 nfet_03v3 ad=4.4p pd=20.88u as=2.6p ps=10.52u w=10u l=0.28u
X32 VSS.t22 REST_BIAS.t7 a_n852_28800.t3 VSS.t20 nfet_03v3 ad=3.12p pd=12.52u as=5.28p ps=24.88u w=12u l=0.28u
X33 VSS.t79 RX_BIAS.t11 a_n5052_2600.t6 VSS.t78 nfet_03v3 ad=0.52p pd=2.52u as=0.52p ps=2.52u w=2u l=0.28u
X34 a_n5052_n1000.t3 RXP.t1 a_n6572_3500.t4 VSS.t74 nfet_03v3 ad=2.6p pd=10.52u as=4.4p ps=20.88u w=10u l=0.28u
X35 a_948_44200.t4 RX_RESTN.t6 EVEN_P.t3 VSS.t70 nfet_03v3 ad=1.56p pd=6.52u as=2.64p ps=12.88u w=6u l=0.28u
X36 a_948_44200.t2 RX_RESTP.t6 EVEN_N.t2 VSS.t50 nfet_03v3 ad=1.56p pd=6.52u as=2.64p ps=12.88u w=6u l=0.28u
X37 VSS.t35 SAMP_BIAS.t7 a_2148_41600.t2 VSS.t34 nfet_03v3 ad=2.6p pd=10.52u as=4.4p ps=20.88u w=10u l=0.28u
X38 EVEN_P.t2 EVEN_N.t5 a_2548_44200.t3 VSS.t62 nfet_03v3 ad=2.64p pd=12.88u as=1.56p ps=6.52u w=6u l=0.28u
X39 a_12148_44200.t2 ODD_P.t6 ODD_N.t0 VSS.t12 nfet_03v3 ad=1.56p pd=6.52u as=2.64p ps=12.88u w=6u l=0.28u
X40 a_2148_41600.t5 SAMP_BIAS.t4 VSS.t41 VSS.t40 nfet_03v3 ad=4.4p pd=20.88u as=2.6p ps=10.52u w=10u l=0.28u
X41 ODD_P.t4 RX_RESTN.t3 a_10548_44200.t5 VSS.t73 nfet_03v3 ad=2.64p pd=12.88u as=1.56p ps=6.52u w=6u l=0.28u
X42 a_2148_n500.t1 a_n3600_5641.t7 RX_RAWN.t1 VSS.t9 nfet_03v3 ad=1.3p pd=5.52u as=2.2p ps=10.88u w=5u l=0.28u
X43 a_2148_41600.t7 SAMP_CLK_N.t3 a_2548_44200.t4 VSS.t63 nfet_03v3 ad=2.08p pd=8.52u as=3.52p ps=16.88u w=8u l=0.28u
X44 ODD_N.t2 RX_RESTP.t3 a_10548_44200.t1 VSS.t53 nfet_03v3 ad=2.64p pd=12.88u as=1.56p ps=6.52u w=6u l=0.28u
X45 VDD.t7 a_n1000_22678.t0 VSS.t6 ppolyf_u r_width=2u r_length=4.2u
X46 a_n5052_n1000.t0 RXN.t1 a_n3600_5641.t2 VSS.t67 nfet_03v3 ad=2.6p pd=10.52u as=4.4p ps=20.88u w=10u l=0.28u
X47 VSS.t97 RX_BIAS.t5 a_n5052_n1000.t8 VSS.t96 nfet_03v3 ad=4.4p pd=20.88u as=2.6p ps=10.52u w=10u l=0.28u
X48 VDD.t5 RX_RESTP.t1 VSS.t6 ppolyf_u r_width=2u r_length=4.2u
X49 a_12148_44200.t5 SAMP_CLK_P.t0 a_11748_41600.t0 VSS.t33 nfet_03v3 ad=3.52p pd=16.88u as=2.08p ps=8.52u w=8u l=0.28u
X50 VSS.t39 SAMP_BIAS.t5 a_2148_41600.t4 VSS.t38 nfet_03v3 ad=2.6p pd=10.52u as=2.6p ps=10.52u w=10u l=0.28u
X51 VDD.t9 a_n6572_3500.t1 VSS.t16 ppolyf_u r_width=2u r_length=4.57u
X52 VDD.t18 EVEN_N.t4 VSS.t76 ppolyf_u r_width=2u r_length=5u
X53 a_2548_44200.t2 EVEN_N.t6 EVEN_P.t1 VSS.t61 nfet_03v3 ad=1.56p pd=6.52u as=2.64p ps=12.88u w=6u l=0.28u
X54 a_n852_28800.t2 a_n1000_22678.t4 RX_RESTP.t2 VSS.t8 nfet_03v3 ad=2.6p pd=10.52u as=4.4p ps=20.88u w=10u l=0.28u
X55 VSS.t26 REST_BIAS.t5 a_n852_28800.t5 VSS.t25 nfet_03v3 ad=3.12p pd=12.52u as=3.12p ps=12.52u w=12u l=0.28u
X56 VSS.t28 REST_BIAS.t1 a_n852_19400.t4 VSS.t25 nfet_03v3 ad=3.12p pd=12.52u as=3.12p ps=12.52u w=12u l=0.28u
X57 VDD.t16 a_5300_5958.t1 VSS.t60 ppolyf_u r_width=1u r_length=1.4u
X58 a_10548_44200.t4 RX_RESTN.t4 ODD_P.t3 VSS.t72 nfet_03v3 ad=1.56p pd=6.52u as=2.64p ps=12.88u w=6u l=0.28u
X59 a_948_44200.t1 SAMP_CLK_P.t2 a_2148_41600.t1 VSS.t31 nfet_03v3 ad=3.52p pd=16.88u as=2.08p ps=8.52u w=8u l=0.28u
X60 a_n852_19400.t7 RX_RAWP.t5 a_n1000_22678.t1 VSS.t8 nfet_03v3 ad=2.6p pd=10.52u as=4.4p ps=20.88u w=10u l=0.28u
X61 VSS.t91 RX_BIAS.t7 a_n5052_n1000.t6 VSS.t90 nfet_03v3 ad=2.6p pd=10.52u as=2.6p ps=10.52u w=10u l=0.28u
X62 RX_RAWP.t2 a_n6572_3500.t6 a_2148_n500.t3 VSS.t11 nfet_03v3 ad=2.2p pd=10.88u as=1.3p ps=5.52u w=5u l=0.28u
X63 a_10548_44200.t0 RX_RESTP.t4 ODD_N.t3 VSS.t52 nfet_03v3 ad=1.56p pd=6.52u as=2.64p ps=12.88u w=6u l=0.28u
X64 a_11748_41600.t5 SAMP_BIAS.t0 VSS.t49 VSS.t48 nfet_03v3 ad=4.4p pd=20.88u as=2.6p ps=10.52u w=10u l=0.28u
X65 VDD.t6 a_600_22678.t0 VSS.t7 ppolyf_u r_width=2u r_length=4.2u
X66 EVEN_N.t1 EVEN_P.t5 a_2548_44200.t1 VSS.t55 nfet_03v3 ad=2.64p pd=12.88u as=1.56p ps=6.52u w=6u l=0.28u
X67 ODD_P.t1 ODD_N.t5 a_12148_44200.t1 VSS.t2 nfet_03v3 ad=2.64p pd=12.88u as=1.56p ps=6.52u w=6u l=0.28u
X68 VDD.t13 RX_RESTN.t2 VSS.t7 ppolyf_u r_width=2u r_length=4.2u
X69 VDD.t0 a_n1900_5958.t0 VSS.t0 ppolyf_u r_width=1u r_length=1.4u
X70 a_n6572_3500.t3 VTHP.t0 a_n5052_2600.t1 VSS.t75 nfet_03v3 ad=0.88p pd=4.88u as=0.52p ps=2.52u w=2u l=0.28u
X71 a_2148_n500.t5 RX_BIAS.t3 VSS.t93 VSS.t92 nfet_03v3 ad=2.6p pd=10.52u as=2.6p ps=10.52u w=10u l=0.28u
X72 a_11748_41600.t1 SAMP_CLK_P.t1 a_12148_44200.t4 VSS.t32 nfet_03v3 ad=2.08p pd=8.52u as=3.52p ps=16.88u w=8u l=0.28u
X73 VDD.t17 a_n6716_3500.t1 VSS.t69 ppolyf_u r_width=1u r_length=1.4u
X74 a_n5052_2600.t0 VTHP.t1 a_n6572_3500.t2 VSS.t74 nfet_03v3 ad=0.52p pd=2.52u as=0.88p ps=4.88u w=2u l=0.28u
X75 a_2148_41600.t3 SAMP_BIAS.t6 VSS.t37 VSS.t36 nfet_03v3 ad=2.6p pd=10.52u as=2.6p ps=10.52u w=10u l=0.28u
X76 VSS.t43 SAMP_BIAS.t3 a_11748_41600.t2 VSS.t42 nfet_03v3 ad=2.6p pd=10.52u as=4.4p ps=20.88u w=10u l=0.28u
X77 VDD.t15 a_n3600_5641.t1 VSS.t59 ppolyf_u r_width=2u r_length=4.57u
X78 a_5300_5958.t0 RX_BW_EN_N.t0 RX_RAWN.t0 VDD.t4 pfet_03v3 ad=2.2p pd=10.88u as=2.2p ps=10.88u w=5u l=0.28u
X79 RX_RESTP.t0 a_n1000_22678.t3 a_n852_28800.t1 VSS.t5 nfet_03v3 ad=4.4p pd=20.88u as=2.6p ps=10.52u w=10u l=0.28u
X80 a_n1000_22678.t2 RX_RAWP.t4 a_n852_19400.t6 VSS.t5 nfet_03v3 ad=4.4p pd=20.88u as=2.6p ps=10.52u w=10u l=0.28u
X81 a_n3600_5641.t3 RXN.t0 a_n5052_n1000.t1 VSS.t68 nfet_03v3 ad=4.4p pd=20.88u as=2.6p ps=10.52u w=10u l=0.28u
X82 VDD.t8 EVEN_P.t0 VSS.t15 ppolyf_u r_width=2u r_length=5u
X83 a_2148_41600.t0 SAMP_CLK_P.t3 a_948_44200.t0 VSS.t30 nfet_03v3 ad=2.08p pd=8.52u as=3.52p ps=16.88u w=8u l=0.28u
X84 a_n852_19400.t3 REST_BIAS.t2 VSS.t27 VSS.t18 nfet_03v3 ad=3.12p pd=12.52u as=3.12p ps=12.52u w=12u l=0.28u
X85 VDD.t10 RX_RAWP.t3 VSS.t17 ppolyf_u r_width=2u r_length=3.43u
X86 a_n5052_n1000.t7 RX_BIAS.t6 VSS.t99 VSS.t98 nfet_03v3 ad=2.6p pd=10.52u as=2.6p ps=10.52u w=10u l=0.28u
X87 a_2148_n500.t7 RX_BIAS.t1 VSS.t103 VSS.t102 nfet_03v3 ad=2.6p pd=10.52u as=2.6p ps=10.52u w=10u l=0.28u
X88 a_n852_28800.t4 REST_BIAS.t6 VSS.t19 VSS.t18 nfet_03v3 ad=3.12p pd=12.52u as=3.12p ps=12.52u w=12u l=0.28u
X89 VSS.t87 RX_BIAS.t9 a_n5052_n1000.t4 VSS.t86 nfet_03v3 ad=2.6p pd=10.52u as=4.4p ps=20.88u w=10u l=0.28u
X90 VDD.t12 ODD_N.t4 VSS.t57 ppolyf_u r_width=2u r_length=5u
X91 a_2548_44200.t0 EVEN_P.t6 EVEN_N.t0 VSS.t54 nfet_03v3 ad=1.56p pd=6.52u as=2.64p ps=12.88u w=6u l=0.28u
X92 VSS.t47 SAMP_BIAS.t1 a_11748_41600.t4 VSS.t46 nfet_03v3 ad=2.6p pd=10.52u as=2.6p ps=10.52u w=10u l=0.28u
X93 VDD.t14 a_484_3500.t1 VSS.t58 ppolyf_u r_width=1u r_length=1.4u
R0 RXN.n0 RXN.t1 139.689
R1 RXN.n0 RXN.t0 139.689
R2 RXN RXN.n0 25.2877
R3 RXP.n0 RXP.t1 139.689
R4 RXP.n0 RXP.t0 139.689
R5 RXP RXP.n0 25.2877
R6 RX_BIAS.n4 RX_BIAS.t4 139.702
R7 RX_BIAS.n0 RX_BIAS.t0 139.702
R8 RX_BIAS.n15 RX_BIAS.t9 139.702
R9 RX_BIAS.n11 RX_BIAS.t5 139.702
R10 RX_BIAS.n1 RX_BIAS.t1 135.246
R11 RX_BIAS.n2 RX_BIAS.t2 135.246
R12 RX_BIAS.n3 RX_BIAS.t3 135.246
R13 RX_BIAS.n12 RX_BIAS.t6 135.246
R14 RX_BIAS.n13 RX_BIAS.t7 135.246
R15 RX_BIAS.n14 RX_BIAS.t8 135.246
R16 RX_BIAS.n6 RX_BIAS.t10 35.4171
R17 RX_BIAS.n9 RX_BIAS.t13 35.4171
R18 RX_BIAS.n7 RX_BIAS.t11 30.9603
R19 RX_BIAS.n8 RX_BIAS.t12 30.9603
R20 RX_BIAS.n17 RX_BIAS.n10 21.4384
R21 RX_BIAS.n18 RX_BIAS.n5 18.9479
R22 RX_BIAS.n5 RX_BIAS.n2 18.4942
R23 RX_BIAS.n16 RX_BIAS.n13 18.4942
R24 RX_BIAS.n17 RX_BIAS.n16 18.0005
R25 RX_BIAS.n8 RX_BIAS.n7 11.6805
R26 RX_BIAS.n2 RX_BIAS.n1 11.6805
R27 RX_BIAS.n3 RX_BIAS.n2 11.6805
R28 RX_BIAS.n13 RX_BIAS.n12 11.6805
R29 RX_BIAS.n14 RX_BIAS.n13 11.6805
R30 RX_BIAS RX_BIAS.n18 7.56892
R31 RX_BIAS.n5 RX_BIAS.n0 7.16487
R32 RX_BIAS.n5 RX_BIAS.n4 7.16487
R33 RX_BIAS.n16 RX_BIAS.n11 7.16487
R34 RX_BIAS.n16 RX_BIAS.n15 7.16487
R35 RX_BIAS.n10 RX_BIAS.n6 7.09873
R36 RX_BIAS.n10 RX_BIAS.n9 7.09873
R37 RX_BIAS.n7 RX_BIAS.n6 4.42851
R38 RX_BIAS.n9 RX_BIAS.n8 4.42851
R39 RX_BIAS.n1 RX_BIAS.n0 4.42851
R40 RX_BIAS.n4 RX_BIAS.n3 4.42851
R41 RX_BIAS.n12 RX_BIAS.n11 4.42851
R42 RX_BIAS.n15 RX_BIAS.n14 4.42851
R43 RX_BIAS.n18 RX_BIAS.n17 0.947868
R44 VTHN.n0 VTHN.t0 35.4171
R45 VTHN.n0 VTHN.t1 35.3883
R46 VTHN VTHN.n0 35.0111
R47 VTHP.n0 VTHP.t1 35.4171
R48 VTHP.n0 VTHP.t0 35.3883
R49 VTHP VTHP.n0 34.2271
R50 RX_BW_EN_N.n0 RX_BW_EN_N.t0 104.718
R51 RX_BW_EN_N.n2 RX_BW_EN_N.t3 102.35
R52 RX_BW_EN_N.n1 RX_BW_EN_N.t2 102.35
R53 RX_BW_EN_N.n0 RX_BW_EN_N.t1 102.35
R54 RX_BW_EN_N RX_BW_EN_N.n2 2.55971
R55 RX_BW_EN_N.n2 RX_BW_EN_N.n1 2.36892
R56 RX_BW_EN_N.n1 RX_BW_EN_N.n0 1.89524
R57 RX_RAWN.n0 RX_RAWN.t4 139.689
R58 RX_RAWN.n0 RX_RAWN.t5 139.689
R59 RX_RAWN RX_RAWN.n0 36.4661
R60 RX_RAWN.n3 RX_RAWN.t3 12.5711
R61 RX_RAWN.n2 RX_RAWN.t0 10.6142
R62 RX_RAWN RX_RAWN.n3 6.39524
R63 RX_RAWN.n1 RX_RAWN.t1 6.0676
R64 RX_RAWN.n1 RX_RAWN.t2 6.06436
R65 RX_RAWN.n2 RX_RAWN.n1 3.78254
R66 RX_RAWN.n3 RX_RAWN.n2 0.491409
R67 RX_RAWP.n0 RX_RAWP.t4 139.689
R68 RX_RAWP.n0 RX_RAWP.t5 139.689
R69 RX_RAWP RX_RAWP.n0 36.3761
R70 RX_RAWP.n3 RX_RAWP.t3 12.5711
R71 RX_RAWP.n2 RX_RAWP.t0 10.6142
R72 RX_RAWP RX_RAWP.n3 6.39524
R73 RX_RAWP.n1 RX_RAWP.t2 6.0676
R74 RX_RAWP.n1 RX_RAWP.t1 6.06436
R75 RX_RAWP.n2 RX_RAWP.n1 3.78254
R76 RX_RAWP.n3 RX_RAWP.n2 0.491409
R77 REST_BIAS.n8 REST_BIAS.t3 165.774
R78 REST_BIAS.n5 REST_BIAS.t0 165.774
R79 REST_BIAS.n0 REST_BIAS.t4 165.774
R80 REST_BIAS.n3 REST_BIAS.t7 165.774
R81 REST_BIAS.n6 REST_BIAS.t1 161.317
R82 REST_BIAS.n7 REST_BIAS.t2 161.317
R83 REST_BIAS.n1 REST_BIAS.t5 161.317
R84 REST_BIAS.n2 REST_BIAS.t6 161.317
R85 REST_BIAS.n10 REST_BIAS.n4 19.0663
R86 REST_BIAS.n10 REST_BIAS.n9 13.5005
R87 REST_BIAS.n7 REST_BIAS.n6 11.6805
R88 REST_BIAS.n2 REST_BIAS.n1 11.6805
R89 REST_BIAS.n9 REST_BIAS.n5 7.10487
R90 REST_BIAS.n9 REST_BIAS.n8 7.10487
R91 REST_BIAS.n4 REST_BIAS.n0 7.10487
R92 REST_BIAS.n4 REST_BIAS.n3 7.10487
R93 REST_BIAS REST_BIAS.n10 6.38708
R94 REST_BIAS.n6 REST_BIAS.n5 4.42851
R95 REST_BIAS.n8 REST_BIAS.n7 4.42851
R96 REST_BIAS.n1 REST_BIAS.n0 4.42851
R97 REST_BIAS.n3 REST_BIAS.n2 4.42851
R98 SAMP_BIAS.n3 SAMP_BIAS.t3 139.702
R99 SAMP_BIAS.n0 SAMP_BIAS.t0 139.702
R100 SAMP_BIAS.n5 SAMP_BIAS.t4 139.702
R101 SAMP_BIAS.n8 SAMP_BIAS.t7 139.702
R102 SAMP_BIAS.n1 SAMP_BIAS.t1 135.246
R103 SAMP_BIAS.n2 SAMP_BIAS.t2 135.246
R104 SAMP_BIAS.n6 SAMP_BIAS.t5 135.246
R105 SAMP_BIAS.n7 SAMP_BIAS.t6 135.246
R106 SAMP_BIAS.n10 SAMP_BIAS.n4 19.1847
R107 SAMP_BIAS.n10 SAMP_BIAS.n9 13.5005
R108 SAMP_BIAS SAMP_BIAS.n10 12.8674
R109 SAMP_BIAS.n2 SAMP_BIAS.n1 11.6805
R110 SAMP_BIAS.n7 SAMP_BIAS.n6 11.6805
R111 SAMP_BIAS.n4 SAMP_BIAS.n0 7.10487
R112 SAMP_BIAS.n4 SAMP_BIAS.n3 7.10487
R113 SAMP_BIAS.n9 SAMP_BIAS.n5 7.10487
R114 SAMP_BIAS.n9 SAMP_BIAS.n8 7.10487
R115 SAMP_BIAS.n1 SAMP_BIAS.n0 4.42851
R116 SAMP_BIAS.n3 SAMP_BIAS.n2 4.42851
R117 SAMP_BIAS.n6 SAMP_BIAS.n5 4.42851
R118 SAMP_BIAS.n8 SAMP_BIAS.n7 4.42851
R119 SAMP_CLK_N.n1 SAMP_CLK_N.t1 113.618
R120 SAMP_CLK_N.n1 SAMP_CLK_N.t0 113.618
R121 SAMP_CLK_N.n0 SAMP_CLK_N.t3 113.618
R122 SAMP_CLK_N.n0 SAMP_CLK_N.t2 113.618
R123 SAMP_CLK_N.n2 SAMP_CLK_N.n1 25.1703
R124 SAMP_CLK_N.n2 SAMP_CLK_N.n0 20.9071
R125 SAMP_CLK_N SAMP_CLK_N.n2 13.1872
R126 SAMP_CLK_P.n1 SAMP_CLK_P.t1 113.618
R127 SAMP_CLK_P.n1 SAMP_CLK_P.t0 113.618
R128 SAMP_CLK_P.n0 SAMP_CLK_P.t3 113.618
R129 SAMP_CLK_P.n0 SAMP_CLK_P.t2 113.618
R130 SAMP_CLK_P.n2 SAMP_CLK_P.n1 28.3203
R131 SAMP_CLK_P.n2 SAMP_CLK_P.n0 25.1624
R132 SAMP_CLK_P SAMP_CLK_P.n2 5.7165
R133 RX_RESTP.n1 RX_RESTP.t5 87.5461
R134 RX_RESTP.n1 RX_RESTP.t6 87.5461
R135 RX_RESTP.n0 RX_RESTP.t3 87.5461
R136 RX_RESTP.n0 RX_RESTP.t4 87.5461
R137 RX_RESTP.n2 RX_RESTP.n0 31.2488
R138 RX_RESTP.n2 RX_RESTP.n1 25.5646
R139 RX_RESTP RX_RESTP.n2 14.1979
R140 RX_RESTP.n4 RX_RESTP.t1 12.57
R141 RX_RESTP RX_RESTP.n4 11.8991
R142 RX_RESTP.n3 RX_RESTP.t2 6.0613
R143 RX_RESTP.n3 RX_RESTP.t0 6.0613
R144 RX_RESTP.n4 RX_RESTP.n3 2.77532
R145 RX_RESTN.n0 RX_RESTN.t5 87.5461
R146 RX_RESTN.n0 RX_RESTN.t6 87.5461
R147 RX_RESTN.n1 RX_RESTN.t3 87.5461
R148 RX_RESTN.n1 RX_RESTN.t4 87.5461
R149 RX_RESTN.n2 RX_RESTN.n1 22.0262
R150 RX_RESTN.n2 RX_RESTN.n0 16.342
R151 RX_RESTN.n4 RX_RESTN.t2 12.57
R152 RX_RESTN RX_RESTN.n4 9.30958
R153 RX_RESTN RX_RESTN.n2 9.17813
R154 RX_RESTN.n3 RX_RESTN.t1 6.0613
R155 RX_RESTN.n3 RX_RESTN.t0 6.0613
R156 RX_RESTN.n4 RX_RESTN.n3 2.77532
R157 ODD_N.n1 ODD_N.t5 87.5461
R158 ODD_N.n1 ODD_N.t6 87.5461
R159 ODD_N.n2 ODD_N.n1 26.3217
R160 ODD_N.n9 ODD_N.t4 12.4596
R161 ODD_N ODD_N.n9 9.32426
R162 ODD_N.n0 ODD_N.t2 5.96544
R163 ODD_N.n0 ODD_N.t3 5.9622
R164 ODD_N.n5 ODD_N.t1 5.87051
R165 ODD_N.n4 ODD_N.t0 5.87051
R166 ODD_N.n4 ODD_N.n3 4.5005
R167 ODD_N.n6 ODD_N.n5 4.5005
R168 ODD_N.n8 ODD_N.n0 2.56391
R169 ODD_N.n9 ODD_N.n8 0.8805
R170 ODD_N.n7 ODD_N.n2 0.419
R171 ODD_N.n8 ODD_N.n7 0.2415
R172 ODD_N.n5 ODD_N.n4 0.189974
R173 ODD_N.n6 ODD_N.n3 0.1605
R174 ODD_N.n7 ODD_N.n6 0.0795
R175 ODD_N.n3 ODD_N.n2 0.0740593
R176 ODD_P.n0 ODD_P.t5 87.5461
R177 ODD_P.n0 ODD_P.t6 87.5461
R178 ODD_P.n1 ODD_P.n0 35.3132
R179 ODD_P.n9 ODD_P.t2 12.4596
R180 ODD_P ODD_P.n9 9.32426
R181 ODD_P.n7 ODD_P.t3 5.96544
R182 ODD_P.n7 ODD_P.t4 5.9622
R183 ODD_P.n3 ODD_P.t1 5.87051
R184 ODD_P.n4 ODD_P.t0 5.87051
R185 ODD_P.n5 ODD_P.n4 4.5005
R186 ODD_P.n3 ODD_P.n2 4.5005
R187 ODD_P.n8 ODD_P.n7 2.56391
R188 ODD_P.n9 ODD_P.n8 0.8805
R189 ODD_P.n6 ODD_P.n1 0.419
R190 ODD_P.n8 ODD_P.n6 0.2415
R191 ODD_P.n4 ODD_P.n3 0.189974
R192 ODD_P.n5 ODD_P.n2 0.1605
R193 ODD_P.n6 ODD_P.n5 0.0795
R194 ODD_P.n2 ODD_P.n1 0.0405
R195 EVEN_N.n1 EVEN_N.t5 87.5461
R196 EVEN_N.n1 EVEN_N.t6 87.5461
R197 EVEN_N.n2 EVEN_N.n1 26.3484
R198 EVEN_N.n9 EVEN_N.t4 12.4596
R199 EVEN_N EVEN_N.n9 9.32426
R200 EVEN_N.n0 EVEN_N.t3 5.96544
R201 EVEN_N.n0 EVEN_N.t2 5.9622
R202 EVEN_N.n5 EVEN_N.t1 5.87051
R203 EVEN_N.n4 EVEN_N.t0 5.87051
R204 EVEN_N.n4 EVEN_N.n3 4.5005
R205 EVEN_N.n6 EVEN_N.n5 4.5005
R206 EVEN_N.n8 EVEN_N.n0 2.56391
R207 EVEN_N.n9 EVEN_N.n8 0.8805
R208 EVEN_N.n7 EVEN_N.n2 0.419
R209 EVEN_N.n8 EVEN_N.n7 0.2415
R210 EVEN_N.n5 EVEN_N.n4 0.189974
R211 EVEN_N.n6 EVEN_N.n3 0.1605
R212 EVEN_N.n7 EVEN_N.n6 0.0795
R213 EVEN_N.n3 EVEN_N.n2 0.0405
R214 EVEN_P.n0 EVEN_P.t5 87.5461
R215 EVEN_P.n0 EVEN_P.t6 87.5461
R216 EVEN_P.n1 EVEN_P.n0 35.155
R217 EVEN_P.n9 EVEN_P.t0 12.4596
R218 EVEN_P EVEN_P.n9 9.32426
R219 EVEN_P.n7 EVEN_P.t3 5.96544
R220 EVEN_P.n7 EVEN_P.t4 5.9622
R221 EVEN_P.n3 EVEN_P.t2 5.87051
R222 EVEN_P.n4 EVEN_P.t1 5.87051
R223 EVEN_P.n5 EVEN_P.n4 4.5005
R224 EVEN_P.n3 EVEN_P.n2 4.5005
R225 EVEN_P.n8 EVEN_P.n7 2.56391
R226 EVEN_P.n9 EVEN_P.n8 0.8805
R227 EVEN_P.n6 EVEN_P.n1 0.419
R228 EVEN_P.n8 EVEN_P.n6 0.2415
R229 EVEN_P.n4 EVEN_P.n3 0.189974
R230 EVEN_P.n5 EVEN_P.n2 0.1605
R231 EVEN_P.n6 EVEN_P.n5 0.0795
R232 EVEN_P.n2 EVEN_P.n1 0.0740593
R233 VDD.t2 VDD.t1 2823.53
R234 VDD.t4 VDD.t3 2823.53
R235 VDD.t3 VDD.t2 1411.76
R236 VDD.n10 VDD.t4 407.682
R237 VDD.n3 VDD.t17 25.1121
R238 VDD.n5 VDD.t0 24.7565
R239 VDD.n9 VDD.t16 24.7565
R240 VDD.n6 VDD.t14 24.7565
R241 VDD.n0 VDD.t8 22.1461
R242 VDD.n11 VDD.t7 21.9006
R243 VDD.n12 VDD.t5 21.9006
R244 VDD.n11 VDD.t6 21.545
R245 VDD.n12 VDD.t13 21.545
R246 VDD.n8 VDD.t19 21.4505
R247 VDD.n7 VDD.t10 21.4505
R248 VDD.n0 VDD.t18 21.435
R249 VDD.n2 VDD.t12 21.435
R250 VDD.n1 VDD.t11 21.435
R251 VDD.n4 VDD.t15 21.3935
R252 VDD.n3 VDD.t9 21.3935
R253 VDD.n14 VDD.n10 3.0962
R254 VDD.n13 VDD.n11 2.26494
R255 VDD.n14 VDD.n13 2.20416
R256 VDD.n1 VDD.n0 1.03676
R257 VDD VDD.n2 0.893155
R258 VDD VDD.n14 0.735495
R259 VDD.n6 VDD.n5 0.451962
R260 VDD.n4 VDD.n3 0.356056
R261 VDD.n5 VDD.n4 0.356056
R262 VDD.n2 VDD.n1 0.337342
R263 VDD.n13 VDD.n12 0.227751
R264 VDD.n7 VDD.n6 0.168921
R265 VDD.n8 VDD.n7 0.168921
R266 VDD.n9 VDD.n8 0.168921
R267 VDD.n10 VDD.n9 0.0678684
R268 VSS.n377 VSS.n376 5319.91
R269 VSS.n376 VSS.n375 722.801
R270 VSS.n353 VSS.n47 312
R271 VSS.n351 VSS.n61 312
R272 VSS.n345 VSS.n61 312
R273 VSS.n345 VSS.n344 312
R274 VSS.t68 VSS.n351 291.2
R275 VSS.n337 VSS.t10 291.2
R276 VSS.n323 VSS.n68 223.625
R277 VSS.n323 VSS.n322 223.625
R278 VSS.n322 VSS.n321 223.625
R279 VSS.n321 VSS.n72 223.625
R280 VSS.n315 VSS.n72 223.625
R281 VSS.n315 VSS.n314 223.625
R282 VSS.n337 VSS.n335 208
R283 VSS.n334 VSS.n333 200.871
R284 VSS.t74 VSS.n353 187.201
R285 VSS.n344 VSS.t3 187.201
R286 VSS.n376 VSS.n42 179.267
R287 VSS.n375 VSS.n47 135.201
R288 VSS.n314 VSS.n313 111.812
R289 VSS.t96 VSS.t67 104.001
R290 VSS.t9 VSS.t104 104.001
R291 VSS.n335 VSS.n334 93.6005
R292 VSS.n354 VSS.t75 83.2005
R293 VSS.t11 VSS.n343 83.2005
R294 VSS.n297 VSS.n296 77.3815
R295 VSS.n297 VSS.n86 77.3815
R296 VSS.n303 VSS.n86 77.3815
R297 VSS.n151 VSS.n150 77.3815
R298 VSS.n382 VSS.n43 59.5005
R299 VSS.n293 VSS.n93 59.5005
R300 VSS.n253 VSS.n177 59.5005
R301 VSS.n255 VSS.n254 59.5005
R302 VSS.n387 VSS.n41 56.0347
R303 VSS.n359 VSS.n58 52.5005
R304 VSS.n355 VSS.n58 52.5005
R305 VSS.n355 VSS.n60 52.5005
R306 VSS.n350 VSS.n60 52.5005
R307 VSS.n350 VSS.n62 52.5005
R308 VSS.n346 VSS.n62 52.5005
R309 VSS.n346 VSS.n64 52.5005
R310 VSS.n342 VSS.n64 52.5005
R311 VSS.n342 VSS.n65 52.5005
R312 VSS.n338 VSS.n65 52.5005
R313 VSS.n369 VSS.n368 52.5005
R314 VSS.n373 VSS.n51 52.5005
R315 VSS.n50 VSS.n46 52.5005
R316 VSS.n377 VSS.n46 52.5005
R317 VSS.n378 VSS.n377 52.5005
R318 VSS.n382 VSS.n40 52.5005
R319 VSS.n388 VSS.n40 52.5005
R320 VSS.n388 VSS.n37 52.5005
R321 VSS.n392 VSS.n37 52.5005
R322 VSS.n392 VSS.n36 52.5005
R323 VSS.n181 VSS.n36 52.5005
R324 VSS.n190 VSS.n181 52.5005
R325 VSS.n190 VSS.n186 52.5005
R326 VSS.n186 VSS.n95 52.5005
R327 VSS.n288 VSS.n95 52.5005
R328 VSS.n333 VSS.n69 52.5005
R329 VSS.n324 VSS.n69 52.5005
R330 VSS.n324 VSS.n71 52.5005
R331 VSS.n320 VSS.n71 52.5005
R332 VSS.n320 VSS.n73 52.5005
R333 VSS.n316 VSS.n73 52.5005
R334 VSS.n316 VSS.n75 52.5005
R335 VSS.n92 VSS.n75 52.5005
R336 VSS.n228 VSS.n227 52.5005
R337 VSS.n232 VSS.n231 52.5005
R338 VSS.n236 VSS.n235 52.5005
R339 VSS.n214 VSS.n213 52.5005
R340 VSS.n210 VSS.n209 52.5005
R341 VSS.n207 VSS.n204 52.5005
R342 VSS.n266 VSS.n265 52.5005
R343 VSS.n270 VSS.n269 52.5005
R344 VSS.n272 VSS.n111 52.5005
R345 VSS.n409 VSS.n408 52.5005
R346 VSS.n413 VSS.n21 52.5005
R347 VSS.n416 VSS.n415 52.5005
R348 VSS.n136 VSS.n126 52.5005
R349 VSS.n139 VSS.n138 52.5005
R350 VSS.n143 VSS.n142 52.5005
R351 VSS.n145 VSS.n143 52.5005
R352 VSS.n449 VSS.n4 52.5005
R353 VSS.n175 VSS.n4 52.5005
R354 VSS.n175 VSS.n103 52.5005
R355 VSS.n171 VSS.n103 52.5005
R356 VSS.n171 VSS.n99 52.5005
R357 VSS.n99 VSS.n91 52.5005
R358 VSS.n91 VSS.n90 52.5005
R359 VSS.n163 VSS.n90 52.5005
R360 VSS.n163 VSS.n85 52.5005
R361 VSS.n160 VSS.n85 52.5005
R362 VSS.n160 VSS.n83 52.5005
R363 VSS.n157 VSS.n83 52.5005
R364 VSS.n157 VSS.n77 52.5005
R365 VSS.n152 VSS.n77 52.5005
R366 VSS.n152 VSS.n120 52.5005
R367 VSS.n435 VSS.n434 52.5005
R368 VSS.n439 VSS.n426 52.5005
R369 VSS.n442 VSS.n441 52.5005
R370 VSS.n444 VSS.n7 52.5005
R371 VSS.n448 VSS.n6 52.5005
R372 VSS.n102 VSS.n6 52.5005
R373 VSS.n280 VSS.n102 52.5005
R374 VSS.n280 VSS.n100 52.5005
R375 VSS.n284 VSS.n100 52.5005
R376 VSS.n284 VSS.n89 52.5005
R377 VSS.n298 VSS.n89 52.5005
R378 VSS.n298 VSS.n87 52.5005
R379 VSS.n302 VSS.n87 52.5005
R380 VSS.n302 VSS.n82 52.5005
R381 VSS.n307 VSS.n82 52.5005
R382 VSS.n307 VSS.n79 52.5005
R383 VSS.n311 VSS.n79 52.5005
R384 VSS.n311 VSS.n78 52.5005
R385 VSS.n149 VSS.n78 52.5005
R386 VSS.n360 VSS.n359 50.7505
R387 VSS.n333 VSS.n67 50.7505
R388 VSS.n128 VSS.n120 50.7505
R389 VSS.n449 VSS.n5 50.7505
R390 VSS.n238 VSS.n118 42.0005
R391 VSS.n216 VSS.n34 42.0005
R392 VSS.n276 VSS.n112 42.0005
R393 VSS.n406 VSS.n24 42.0005
R394 VSS.n448 VSS.n7 42.0005
R395 VSS.n149 VSS.n122 42.0005
R396 VSS.t75 VSS.t74 41.6005
R397 VSS.t3 VSS.t11 41.6005
R398 VSS.t92 VSS.t94 41.6005
R399 VSS.t100 VSS.t92 41.6005
R400 VSS.t102 VSS.t100 41.6005
R401 VSS.t104 VSS.t102 41.6005
R402 VSS.n385 VSS.n384 36.8992
R403 VSS.n338 VSS.n67 35.0005
R404 VSS.n288 VSS.n93 35.0005
R405 VSS.n394 VSS.n14 35.0005
R406 VSS.n398 VSS.n14 35.0005
R407 VSS.n398 VSS.n30 35.0005
R408 VSS.n242 VSS.n30 35.0005
R409 VSS.n242 VSS.n118 35.0005
R410 VSS.n34 VSS.n12 35.0005
R411 VSS.n29 VSS.n12 35.0005
R412 VSS.n249 VSS.n29 35.0005
R413 VSS.n249 VSS.n178 35.0005
R414 VSS.n253 VSS.n178 35.0005
R415 VSS.n422 VSS.n16 35.0005
R416 VSS.n422 VSS.n15 35.0005
R417 VSS.n247 VSS.n15 35.0005
R418 VSS.n247 VSS.n244 35.0005
R419 VSS.n244 VSS.n112 35.0005
R420 VSS.n24 VSS.n11 35.0005
R421 VSS.n400 VSS.n11 35.0005
R422 VSS.n400 VSS.n27 35.0005
R423 VSS.n116 VSS.n27 35.0005
R424 VSS.n254 VSS.n116 35.0005
R425 VSS.n383 VSS.n42 33.5322
R426 VSS.n393 VSS.n19 33.5322
R427 VSS.t72 VSS.n303 33.5322
R428 VSS.n151 VSS.t53 33.5322
R429 VSS.n150 VSS.n121 33.5322
R430 VSS.n386 VSS.n385 30.241
R431 VSS.n295 VSS.t51 28.3735
R432 VSS.n334 VSS.n68 27.9535
R433 VSS.n394 VSS.n33 24.5005
R434 VSS.n418 VSS.n16 24.5005
R435 VSS.n304 VSS.t73 23.4727
R436 VSS.t52 VSS.n76 23.4727
R437 VSS.n279 VSS.t34 23.2148
R438 VSS.n306 VSS.t42 23.2148
R439 VSS.n156 VSS.t48 23.2148
R440 VSS.n41 VSS.n19 22.5029
R441 VSS.n452 VSS.n451 21.3764
R442 VSS.n354 VSS.t86 20.8005
R443 VSS.t86 VSS.t82 20.8005
R444 VSS.t82 VSS.t88 20.8005
R445 VSS.t88 VSS.t84 20.8005
R446 VSS.t84 VSS.t90 20.8005
R447 VSS.t90 VSS.t78 20.8005
R448 VSS.t78 VSS.t98 20.8005
R449 VSS.t98 VSS.t80 20.8005
R450 VSS.t80 VSS.t96 20.8005
R451 VSS.t67 VSS.n352 20.8005
R452 VSS.n352 VSS.t68 20.8005
R453 VSS.n343 VSS.t94 20.8005
R454 VSS.n336 VSS.t9 20.8005
R455 VSS.t10 VSS.n336 20.8005
R456 VSS.t76 VSS.t64 20.6354
R457 VSS.t56 VSS.t65 20.6354
R458 VSS.t33 VSS.t57 20.6354
R459 VSS.n453 VSS.n0 19.8518
R460 VSS.n404 VSS.n1 19.1783
R461 VSS.n200 VSS.n1 18.8227
R462 VSS.t30 VSS.n117 17.7981
R463 VSS.t60 VSS.n98 16.5084
R464 VSS.n192 VSS.n191 15.7346
R465 VSS.t61 VSS.t31 15.4767
R466 VSS.t55 VSS.t63 15.4767
R467 VSS.t1 VSS.t66 15.4767
R468 VSS.t13 VSS.t32 15.4767
R469 VSS.n430 VSS.n429 13.5139
R470 VSS.n133 VSS.n132 13.5139
R471 VSS.t20 VSS.n28 13.1553
R472 VSS.t15 VSS.n176 12.8973
R473 VSS.n170 VSS.t77 12.8973
R474 VSS.n84 VSS.t56 12.8973
R475 VSS.n312 VSS.t57 12.8973
R476 VSS.n384 VSS.n383 11.1056
R477 VSS.n393 VSS.n13 11.1056
R478 VSS.n423 VSS.n13 11.1056
R479 VSS.n386 VSS.t16 10.6746
R480 VSS.n41 VSS.t59 10.6746
R481 VSS.n424 VSS.n10 10.5759
R482 VSS.t18 VSS.t20 10.318
R483 VSS.t25 VSS.t18 10.318
R484 VSS.t36 VSS.t34 10.318
R485 VSS.t40 VSS.t38 10.318
R486 VSS.t77 VSS.t40 10.318
R487 VSS.t73 VSS.t72 10.318
R488 VSS.t2 VSS.t1 10.318
R489 VSS.t44 VSS.t42 10.318
R490 VSS.t46 VSS.t44 10.318
R491 VSS.t48 VSS.t46 10.318
R492 VSS.t12 VSS.t13 10.318
R493 VSS.t53 VSS.t52 10.318
R494 VSS.n225 VSS.n224 10.2705
R495 VSS.n257 VSS.n25 10.2705
R496 VSS.n263 VSS.n262 10.2705
R497 VSS.n219 VSS.n218 10.2705
R498 VSS.n35 VSS.n10 10.06
R499 VSS.n399 VSS.n28 10.06
R500 VSS.n193 VSS.t58 10.06
R501 VSS.n182 VSS.n176 10.06
R502 VSS.n286 VSS.n285 10.06
R503 VSS.n304 VSS.n84 10.06
R504 VSS.t76 VSS.n96 9.28621
R505 VSS.n169 VSS.t36 7.99653
R506 VSS.n168 VSS.t55 7.99653
R507 VSS.n287 VSS.t63 7.99653
R508 VSS.t66 VSS.n305 7.99653
R509 VSS.t32 VSS.n155 7.99653
R510 VSS.n35 VSS.t8 7.7386
R511 VSS.n399 VSS.t5 7.7386
R512 VSS.n248 VSS.t25 7.7386
R513 VSS.t58 VSS.t14 7.7386
R514 VSS.n170 VSS.t54 7.7386
R515 VSS.n306 VSS.t2 7.7386
R516 VSS.n156 VSS.t12 7.7386
R517 VSS.n384 VSS.t69 7.34554
R518 VSS.n13 VSS.t0 7.34554
R519 VSS.n195 VSS.t23 6.70685
R520 VSS.n363 VSS.t97 6.57557
R521 VSS.n261 VSS.n258 6.5388
R522 VSS.n260 VSS.n259 6.5388
R523 VSS.n223 VSS.n220 6.5388
R524 VSS.n222 VSS.n221 6.5388
R525 VSS.n56 VSS.n54 6.49615
R526 VSS.n330 VSS.t105 6.45713
R527 VSS.n329 VSS.n328 6.41078
R528 VSS.n429 VSS.n428 6.38826
R529 VSS.n132 VSS.n130 6.38826
R530 VSS.n429 VSS.n427 6.38502
R531 VSS.n132 VSS.n131 6.38502
R532 VSS.n56 VSS.n55 6.31615
R533 VSS.n329 VSS.n327 6.29483
R534 VSS.n363 VSS.n362 6.29483
R535 VSS.n365 VSS.n364 6.29333
R536 VSS.n57 VSS.n56 6.278
R537 VSS.n366 VSS.n365 5.6555
R538 VSS.n331 VSS.n330 5.5955
R539 VSS.n380 VSS.n43 5.2005
R540 VSS.n379 VSS.n378 5.2005
R541 VSS.n377 VSS.n44 5.2005
R542 VSS.n375 VSS.n46 5.2005
R543 VSS.n52 VSS.n46 5.2005
R544 VSS.n53 VSS.n50 5.2005
R545 VSS.n373 VSS.n372 5.2005
R546 VSS.n371 VSS.n51 5.2005
R547 VSS.n370 VSS.n369 5.2005
R548 VSS.n368 VSS.n367 5.2005
R549 VSS.n361 VSS.n360 5.2005
R550 VSS.n97 VSS.n93 5.2005
R551 VSS.n290 VSS.n93 5.2005
R552 VSS.n288 VSS.t76 5.2005
R553 VSS.n289 VSS.n288 5.2005
R554 VSS.t77 VSS.n95 5.2005
R555 VSS.n95 VSS.n94 5.2005
R556 VSS.n186 VSS.n185 5.2005
R557 VSS.n187 VSS.n186 5.2005
R558 VSS.n191 VSS.n190 5.2005
R559 VSS.n190 VSS.n189 5.2005
R560 VSS.n248 VSS.n181 5.2005
R561 VSS.n188 VSS.n181 5.2005
R562 VSS.n36 VSS.n35 5.2005
R563 VSS.n38 VSS.n36 5.2005
R564 VSS.n393 VSS.n392 5.2005
R565 VSS.n392 VSS.n391 5.2005
R566 VSS.t59 VSS.n37 5.2005
R567 VSS.n390 VSS.n37 5.2005
R568 VSS.n388 VSS.n387 5.2005
R569 VSS.n389 VSS.n388 5.2005
R570 VSS.n385 VSS.n40 5.2005
R571 VSS.n40 VSS.n39 5.2005
R572 VSS.n383 VSS.n382 5.2005
R573 VSS.n382 VSS.n381 5.2005
R574 VSS.n333 VSS.n332 5.2005
R575 VSS.n69 VSS.n68 5.2005
R576 VSS.n326 VSS.n69 5.2005
R577 VSS.n324 VSS.n323 5.2005
R578 VSS.n325 VSS.n324 5.2005
R579 VSS.n322 VSS.n71 5.2005
R580 VSS.n71 VSS.n70 5.2005
R581 VSS.n321 VSS.n320 5.2005
R582 VSS.n320 VSS.n319 5.2005
R583 VSS.n73 VSS.n72 5.2005
R584 VSS.n318 VSS.n73 5.2005
R585 VSS.n316 VSS.n315 5.2005
R586 VSS.n317 VSS.n316 5.2005
R587 VSS.n314 VSS.n75 5.2005
R588 VSS.n75 VSS.n74 5.2005
R589 VSS.n291 VSS.n92 5.2005
R590 VSS.n293 VSS.n292 5.2005
R591 VSS.n335 VSS.n67 5.2005
R592 VSS.n67 VSS.n66 5.2005
R593 VSS.n338 VSS.n337 5.2005
R594 VSS.n339 VSS.n338 5.2005
R595 VSS.n336 VSS.n65 5.2005
R596 VSS.n340 VSS.n65 5.2005
R597 VSS.n343 VSS.n342 5.2005
R598 VSS.n342 VSS.n341 5.2005
R599 VSS.n344 VSS.n64 5.2005
R600 VSS.n64 VSS.n63 5.2005
R601 VSS.n346 VSS.n345 5.2005
R602 VSS.n347 VSS.n346 5.2005
R603 VSS.n62 VSS.n61 5.2005
R604 VSS.n348 VSS.n62 5.2005
R605 VSS.n351 VSS.n350 5.2005
R606 VSS.n350 VSS.n349 5.2005
R607 VSS.n352 VSS.n60 5.2005
R608 VSS.n60 VSS.n59 5.2005
R609 VSS.n355 VSS.n354 5.2005
R610 VSS.n356 VSS.n355 5.2005
R611 VSS.n353 VSS.n58 5.2005
R612 VSS.n357 VSS.n58 5.2005
R613 VSS.n359 VSS.n47 5.2005
R614 VSS.n359 VSS.n358 5.2005
R615 VSS.t6 VSS.n448 5.2005
R616 VSS.n448 VSS.n447 5.2005
R617 VSS.n194 VSS.n6 5.2005
R618 VSS.n8 VSS.n6 5.2005
R619 VSS.n176 VSS.n102 5.2005
R620 VSS.n102 VSS.n101 5.2005
R621 VSS.n280 VSS.n279 5.2005
R622 VSS.n281 VSS.n280 5.2005
R623 VSS.n170 VSS.n100 5.2005
R624 VSS.n282 VSS.n100 5.2005
R625 VSS.n285 VSS.n284 5.2005
R626 VSS.n284 VSS.n283 5.2005
R627 VSS.n296 VSS.n89 5.2005
R628 VSS.n89 VSS.n88 5.2005
R629 VSS.n298 VSS.n297 5.2005
R630 VSS.n299 VSS.n298 5.2005
R631 VSS.n87 VSS.n86 5.2005
R632 VSS.n300 VSS.n87 5.2005
R633 VSS.n303 VSS.n302 5.2005
R634 VSS.n302 VSS.n301 5.2005
R635 VSS.n84 VSS.n82 5.2005
R636 VSS.n82 VSS.n81 5.2005
R637 VSS.n307 VSS.n306 5.2005
R638 VSS.n308 VSS.n307 5.2005
R639 VSS.n156 VSS.n79 5.2005
R640 VSS.n309 VSS.n79 5.2005
R641 VSS.n312 VSS.n311 5.2005
R642 VSS.n311 VSS.n310 5.2005
R643 VSS.n151 VSS.n78 5.2005
R644 VSS.n80 VSS.n78 5.2005
R645 VSS.n150 VSS.n149 5.2005
R646 VSS.n149 VSS.n148 5.2005
R647 VSS.n150 VSS.n120 5.2005
R648 VSS.n120 VSS.n119 5.2005
R649 VSS.n152 VSS.n151 5.2005
R650 VSS.n153 VSS.n152 5.2005
R651 VSS.n312 VSS.n77 5.2005
R652 VSS.n154 VSS.n77 5.2005
R653 VSS.n157 VSS.n156 5.2005
R654 VSS.n158 VSS.n157 5.2005
R655 VSS.n306 VSS.n83 5.2005
R656 VSS.n159 VSS.n83 5.2005
R657 VSS.n160 VSS.n84 5.2005
R658 VSS.n161 VSS.n160 5.2005
R659 VSS.n303 VSS.n85 5.2005
R660 VSS.n162 VSS.n85 5.2005
R661 VSS.n163 VSS.n86 5.2005
R662 VSS.n164 VSS.n163 5.2005
R663 VSS.n297 VSS.n90 5.2005
R664 VSS.n165 VSS.n90 5.2005
R665 VSS.n296 VSS.n91 5.2005
R666 VSS.n166 VSS.n91 5.2005
R667 VSS.n285 VSS.n99 5.2005
R668 VSS.n167 VSS.n99 5.2005
R669 VSS.n171 VSS.n170 5.2005
R670 VSS.n172 VSS.n171 5.2005
R671 VSS.n279 VSS.n103 5.2005
R672 VSS.n173 VSS.n103 5.2005
R673 VSS.n176 VSS.n175 5.2005
R674 VSS.n175 VSS.n174 5.2005
R675 VSS.n194 VSS.n4 5.2005
R676 VSS.n4 VSS.n3 5.2005
R677 VSS.n449 VSS.t6 5.2005
R678 VSS.n450 VSS.n449 5.2005
R679 VSS.n424 VSS.n7 5.2005
R680 VSS.n446 VSS.n7 5.2005
R681 VSS.n445 VSS.n444 5.2005
R682 VSS.n442 VSS.n9 5.2005
R683 VSS.n441 VSS.n425 5.2005
R684 VSS.n439 VSS.n438 5.2005
R685 VSS.n437 VSS.n426 5.2005
R686 VSS.n436 VSS.n435 5.2005
R687 VSS.n434 VSS.n431 5.2005
R688 VSS.n5 VSS.n2 5.2005
R689 VSS.n129 VSS.n128 5.2005
R690 VSS.n134 VSS.n126 5.2005
R691 VSS.n136 VSS.n135 5.2005
R692 VSS.n138 VSS.n125 5.2005
R693 VSS.n140 VSS.n139 5.2005
R694 VSS.n142 VSS.n141 5.2005
R695 VSS.n143 VSS.n121 5.2005
R696 VSS.n143 VSS.n123 5.2005
R697 VSS.n146 VSS.n145 5.2005
R698 VSS.n147 VSS.n122 5.2005
R699 VSS.n254 VSS.t15 5.2005
R700 VSS.n254 VSS.n114 5.2005
R701 VSS.n243 VSS.n116 5.2005
R702 VSS.n116 VSS.n115 5.2005
R703 VSS.n248 VSS.n27 5.2005
R704 VSS.n27 VSS.n26 5.2005
R705 VSS.n400 VSS.n399 5.2005
R706 VSS.n401 VSS.n400 5.2005
R707 VSS.n423 VSS.n11 5.2005
R708 VSS.n402 VSS.n11 5.2005
R709 VSS.n393 VSS.n24 5.2005
R710 VSS.n403 VSS.n24 5.2005
R711 VSS.n419 VSS.n418 5.2005
R712 VSS.n416 VSS.n18 5.2005
R713 VSS.n415 VSS.n20 5.2005
R714 VSS.n413 VSS.n412 5.2005
R715 VSS.n411 VSS.n21 5.2005
R716 VSS.n410 VSS.n409 5.2005
R717 VSS.n408 VSS.n22 5.2005
R718 VSS.n406 VSS.n405 5.2005
R719 VSS.n256 VSS.n255 5.2005
R720 VSS.n265 VSS.n264 5.2005
R721 VSS.n267 VSS.n266 5.2005
R722 VSS.n269 VSS.n268 5.2005
R723 VSS.n271 VSS.n270 5.2005
R724 VSS.n273 VSS.n272 5.2005
R725 VSS.n274 VSS.n111 5.2005
R726 VSS.n276 VSS.n275 5.2005
R727 VSS.t15 VSS.n112 5.2005
R728 VSS.n113 VSS.n112 5.2005
R729 VSS.n244 VSS.n243 5.2005
R730 VSS.n245 VSS.n244 5.2005
R731 VSS.n248 VSS.n247 5.2005
R732 VSS.n247 VSS.n246 5.2005
R733 VSS.n399 VSS.n15 5.2005
R734 VSS.n17 VSS.n15 5.2005
R735 VSS.n423 VSS.n422 5.2005
R736 VSS.n422 VSS.n421 5.2005
R737 VSS.n393 VSS.n16 5.2005
R738 VSS.n420 VSS.n16 5.2005
R739 VSS.t15 VSS.n253 5.2005
R740 VSS.n253 VSS.n252 5.2005
R741 VSS.n243 VSS.n178 5.2005
R742 VSS.n251 VSS.n178 5.2005
R743 VSS.n249 VSS.n248 5.2005
R744 VSS.n250 VSS.n249 5.2005
R745 VSS.n399 VSS.n29 5.2005
R746 VSS.n180 VSS.n29 5.2005
R747 VSS.n423 VSS.n12 5.2005
R748 VSS.n198 VSS.n12 5.2005
R749 VSS.n393 VSS.n34 5.2005
R750 VSS.n199 VSS.n34 5.2005
R751 VSS.n33 VSS.n32 5.2005
R752 VSS.n205 VSS.n204 5.2005
R753 VSS.n207 VSS.n206 5.2005
R754 VSS.n209 VSS.n202 5.2005
R755 VSS.n211 VSS.n210 5.2005
R756 VSS.n213 VSS.n212 5.2005
R757 VSS.n214 VSS.n197 5.2005
R758 VSS.n217 VSS.n216 5.2005
R759 VSS.n179 VSS.n177 5.2005
R760 VSS.n227 VSS.n226 5.2005
R761 VSS.n229 VSS.n228 5.2005
R762 VSS.n231 VSS.n230 5.2005
R763 VSS.n233 VSS.n232 5.2005
R764 VSS.n235 VSS.n234 5.2005
R765 VSS.n237 VSS.n236 5.2005
R766 VSS.n239 VSS.n238 5.2005
R767 VSS.t15 VSS.n118 5.2005
R768 VSS.n240 VSS.n118 5.2005
R769 VSS.n243 VSS.n242 5.2005
R770 VSS.n242 VSS.n241 5.2005
R771 VSS.n248 VSS.n30 5.2005
R772 VSS.n31 VSS.n30 5.2005
R773 VSS.n399 VSS.n398 5.2005
R774 VSS.n398 VSS.n397 5.2005
R775 VSS.n423 VSS.n14 5.2005
R776 VSS.n396 VSS.n14 5.2005
R777 VSS.n394 VSS.n393 5.2005
R778 VSS.n395 VSS.n394 5.2005
R779 VSS.n424 VSS.n423 5.15923
R780 VSS.t6 VSS.t8 5.15923
R781 VSS.t6 VSS.t5 5.15923
R782 VSS.t14 VSS.t7 5.15923
R783 VSS.n243 VSS.t70 5.15923
R784 VSS.n243 VSS.t71 5.15923
R785 VSS.t31 VSS.t17 5.15923
R786 VSS.n185 VSS.t62 5.15923
R787 VSS.n279 VSS.n278 5.15923
R788 VSS.t50 VSS.n97 5.15923
R789 VSS.n97 VSS.t51 5.15923
R790 VSS.n296 VSS.n295 5.15923
R791 VSS.n313 VSS.n312 5.15923
R792 VSS.n192 VSS.t71 4.90129
R793 VSS.n313 VSS.n76 4.90129
R794 VSS.n260 VSS.n257 4.5005
R795 VSS.n262 VSS.n261 4.5005
R796 VSS.n222 VSS.n219 4.5005
R797 VSS.n224 VSS.n223 4.5005
R798 VSS.n387 VSS.n386 4.44737
R799 VSS.n45 VSS.n43 4.34122
R800 VSS.n374 VSS.n50 4.34122
R801 VSS.n51 VSS.n49 4.34122
R802 VSS.n368 VSS.n48 4.34122
R803 VSS.n294 VSS.n92 4.34122
R804 VSS.n360 VSS.n48 4.34122
R805 VSS.n369 VSS.n49 4.34122
R806 VSS.n374 VSS.n373 4.34122
R807 VSS.n378 VSS.n45 4.34122
R808 VSS.n294 VSS.n293 4.34122
R809 VSS.n444 VSS.n443 4.34122
R810 VSS.n441 VSS.n440 4.34122
R811 VSS.n432 VSS.n426 4.34122
R812 VSS.n434 VSS.n433 4.34122
R813 VSS.n128 VSS.n127 4.34122
R814 VSS.n137 VSS.n136 4.34122
R815 VSS.n139 VSS.n124 4.34122
R816 VSS.n145 VSS.n144 4.34122
R817 VSS.n418 VSS.n417 4.34122
R818 VSS.n415 VSS.n414 4.34122
R819 VSS.n23 VSS.n21 4.34122
R820 VSS.n408 VSS.n407 4.34122
R821 VSS.n265 VSS.n105 4.34122
R822 VSS.n266 VSS.n110 4.34122
R823 VSS.n272 VSS.n104 4.34122
R824 VSS.n277 VSS.n111 4.34122
R825 VSS.n203 VSS.n33 4.34122
R826 VSS.n208 VSS.n207 4.34122
R827 VSS.n210 VSS.n201 4.34122
R828 VSS.n215 VSS.n214 4.34122
R829 VSS.n177 VSS.n106 4.34122
R830 VSS.n228 VSS.n107 4.34122
R831 VSS.n232 VSS.n108 4.34122
R832 VSS.n236 VSS.n109 4.34122
R833 VSS.n227 VSS.n106 4.34122
R834 VSS.n231 VSS.n107 4.34122
R835 VSS.n235 VSS.n108 4.34122
R836 VSS.n238 VSS.n109 4.34122
R837 VSS.n216 VSS.n215 4.34122
R838 VSS.n213 VSS.n201 4.34122
R839 VSS.n209 VSS.n208 4.34122
R840 VSS.n204 VSS.n203 4.34122
R841 VSS.n255 VSS.n105 4.34122
R842 VSS.n269 VSS.n110 4.34122
R843 VSS.n270 VSS.n104 4.34122
R844 VSS.n277 VSS.n276 4.34122
R845 VSS.n407 VSS.n406 4.34122
R846 VSS.n409 VSS.n23 4.34122
R847 VSS.n414 VSS.n413 4.34122
R848 VSS.n417 VSS.n416 4.34122
R849 VSS.n127 VSS.n126 4.34122
R850 VSS.n138 VSS.n137 4.34122
R851 VSS.n142 VSS.n124 4.34122
R852 VSS.n144 VSS.n122 4.34122
R853 VSS.n433 VSS.n5 4.34122
R854 VSS.n435 VSS.n432 4.34122
R855 VSS.n440 VSS.n439 4.34122
R856 VSS.n443 VSS.n442 4.34122
R857 VSS.n98 VSS.t50 4.12748
R858 VSS.n98 VSS.n96 4.08867
R859 VSS.n196 VSS.n195 4.08867
R860 VSS.n169 VSS.n168 3.63551
R861 VSS.n184 VSS.n117 3.63551
R862 VSS.n195 VSS.n194 3.61161
R863 VSS.n196 VSS.t7 3.61161
R864 VSS.n285 VSS.n96 3.61161
R865 VSS.n155 VSS.n76 3.54389
R866 VSS.n305 VSS.n304 3.54389
R867 VSS.n287 VSS.n286 3.54389
R868 VSS.n183 VSS.n182 3.54389
R869 VSS.n194 VSS.n193 2.8378
R870 VSS.n191 VSS.n182 2.8378
R871 VSS.t15 VSS.n117 2.8378
R872 VSS.t17 VSS.n183 2.8378
R873 VSS.n185 VSS.n184 2.8378
R874 VSS.n286 VSS.t60 2.8378
R875 VSS.n248 VSS.t23 2.57987
R876 VSS.t70 VSS.t4 2.57987
R877 VSS.n278 VSS.t62 2.57987
R878 VSS.n183 VSS.t30 2.32193
R879 VSS.n184 VSS.t61 2.32193
R880 VSS.t38 VSS.n169 2.32193
R881 VSS.n168 VSS.t54 2.32193
R882 VSS.t64 VSS.n287 2.32193
R883 VSS.n305 VSS.t65 2.32193
R884 VSS.n155 VSS.t33 2.32193
R885 VSS.n193 VSS.n192 1.75086
R886 VSS.n28 VSS.n10 1.75086
R887 VSS.t4 VSS.n196 1.54812
R888 VSS.n453 VSS.n452 0.996489
R889 VSS.n452 VSS.n1 0.991003
R890 VSS.n54 VSS.t79 0.8195
R891 VSS.n54 VSS.t81 0.8195
R892 VSS.n55 VSS.t83 0.8195
R893 VSS.n55 VSS.t85 0.8195
R894 VSS.n381 VSS.n380 0.7655
R895 VSS.n292 VSS.n290 0.7655
R896 VSS.n252 VSS.n179 0.7655
R897 VSS.n256 VSS.n114 0.7655
R898 VSS.n370 VSS.n367 0.6755
R899 VSS.n371 VSS.n370 0.6755
R900 VSS.n372 VSS.n371 0.6755
R901 VSS.n53 VSS.n52 0.6755
R902 VSS.n52 VSS.n44 0.6755
R903 VSS.n379 VSS.n44 0.6755
R904 VSS.n380 VSS.n379 0.6755
R905 VSS.n381 VSS.n39 0.6755
R906 VSS.n389 VSS.n39 0.6755
R907 VSS.n390 VSS.n389 0.6755
R908 VSS.n391 VSS.n390 0.6755
R909 VSS.n391 VSS.n38 0.6755
R910 VSS.n188 VSS.n38 0.6755
R911 VSS.n189 VSS.n188 0.6755
R912 VSS.n189 VSS.n187 0.6755
R913 VSS.n187 VSS.n94 0.6755
R914 VSS.n289 VSS.n94 0.6755
R915 VSS.n326 VSS.n325 0.6755
R916 VSS.n325 VSS.n70 0.6755
R917 VSS.n319 VSS.n70 0.6755
R918 VSS.n319 VSS.n318 0.6755
R919 VSS.n318 VSS.n317 0.6755
R920 VSS.n317 VSS.n74 0.6755
R921 VSS.n291 VSS.n74 0.6755
R922 VSS.n292 VSS.n291 0.6755
R923 VSS.n358 VSS.n357 0.6755
R924 VSS.n357 VSS.n356 0.6755
R925 VSS.n356 VSS.n59 0.6755
R926 VSS.n349 VSS.n59 0.6755
R927 VSS.n349 VSS.n348 0.6755
R928 VSS.n348 VSS.n347 0.6755
R929 VSS.n347 VSS.n63 0.6755
R930 VSS.n341 VSS.n63 0.6755
R931 VSS.n341 VSS.n340 0.6755
R932 VSS.n340 VSS.n339 0.6755
R933 VSS.n229 VSS.n226 0.6755
R934 VSS.n230 VSS.n229 0.6755
R935 VSS.n233 VSS.n230 0.6755
R936 VSS.n234 VSS.n233 0.6755
R937 VSS.n237 VSS.n234 0.6755
R938 VSS.n239 VSS.n237 0.6755
R939 VSS.n212 VSS.n197 0.6755
R940 VSS.n212 VSS.n211 0.6755
R941 VSS.n211 VSS.n202 0.6755
R942 VSS.n206 VSS.n202 0.6755
R943 VSS.n206 VSS.n205 0.6755
R944 VSS.n205 VSS.n32 0.6755
R945 VSS.n410 VSS.n22 0.6755
R946 VSS.n411 VSS.n410 0.6755
R947 VSS.n412 VSS.n411 0.6755
R948 VSS.n412 VSS.n20 0.6755
R949 VSS.n20 VSS.n18 0.6755
R950 VSS.n419 VSS.n18 0.6755
R951 VSS.n267 VSS.n264 0.6755
R952 VSS.n268 VSS.n267 0.6755
R953 VSS.n271 VSS.n268 0.6755
R954 VSS.n273 VSS.n271 0.6755
R955 VSS.n274 VSS.n273 0.6755
R956 VSS.n275 VSS.n274 0.6755
R957 VSS.n135 VSS.n134 0.6755
R958 VSS.n135 VSS.n125 0.6755
R959 VSS.n140 VSS.n125 0.6755
R960 VSS.n141 VSS.n140 0.6755
R961 VSS.n141 VSS.n123 0.6755
R962 VSS.n146 VSS.n123 0.6755
R963 VSS.n147 VSS.n146 0.6755
R964 VSS.n450 VSS.n3 0.6755
R965 VSS.n174 VSS.n3 0.6755
R966 VSS.n174 VSS.n173 0.6755
R967 VSS.n173 VSS.n172 0.6755
R968 VSS.n172 VSS.n167 0.6755
R969 VSS.n167 VSS.n166 0.6755
R970 VSS.n166 VSS.n165 0.6755
R971 VSS.n165 VSS.n164 0.6755
R972 VSS.n164 VSS.n162 0.6755
R973 VSS.n162 VSS.n161 0.6755
R974 VSS.n161 VSS.n159 0.6755
R975 VSS.n159 VSS.n158 0.6755
R976 VSS.n158 VSS.n154 0.6755
R977 VSS.n154 VSS.n153 0.6755
R978 VSS.n153 VSS.n119 0.6755
R979 VSS.n436 VSS.n431 0.6755
R980 VSS.n437 VSS.n436 0.6755
R981 VSS.n438 VSS.n437 0.6755
R982 VSS.n438 VSS.n425 0.6755
R983 VSS.n425 VSS.n9 0.6755
R984 VSS.n445 VSS.n9 0.6755
R985 VSS.n446 VSS.n445 0.6755
R986 VSS.n447 VSS.n8 0.6755
R987 VSS.n101 VSS.n8 0.6755
R988 VSS.n281 VSS.n101 0.6755
R989 VSS.n282 VSS.n281 0.6755
R990 VSS.n283 VSS.n282 0.6755
R991 VSS.n283 VSS.n88 0.6755
R992 VSS.n299 VSS.n88 0.6755
R993 VSS.n300 VSS.n299 0.6755
R994 VSS.n301 VSS.n300 0.6755
R995 VSS.n301 VSS.n81 0.6755
R996 VSS.n308 VSS.n81 0.6755
R997 VSS.n309 VSS.n308 0.6755
R998 VSS.n310 VSS.n309 0.6755
R999 VSS.n310 VSS.n80 0.6755
R1000 VSS.n148 VSS.n80 0.6755
R1001 VSS.n332 VSS.n66 0.653
R1002 VSS.n129 VSS.n119 0.653
R1003 VSS.n134 VSS.n133 0.563
R1004 VSS.n431 VSS.n430 0.563
R1005 VSS.n240 VSS.n239 0.5405
R1006 VSS.n275 VSS.n113 0.5405
R1007 VSS.n447 VSS.n446 0.5405
R1008 VSS.n148 VSS.n147 0.5405
R1009 VSS.n367 VSS.n366 0.4505
R1010 VSS.n290 VSS.n289 0.4505
R1011 VSS.n331 VSS.n326 0.4505
R1012 VSS.n339 VSS.n66 0.4505
R1013 VSS.n396 VSS.n395 0.4505
R1014 VSS.n397 VSS.n396 0.4505
R1015 VSS.n397 VSS.n31 0.4505
R1016 VSS.n241 VSS.n31 0.4505
R1017 VSS.n241 VSS.n240 0.4505
R1018 VSS.n199 VSS.n198 0.4505
R1019 VSS.n198 VSS.n180 0.4505
R1020 VSS.n250 VSS.n180 0.4505
R1021 VSS.n251 VSS.n250 0.4505
R1022 VSS.n252 VSS.n251 0.4505
R1023 VSS.n421 VSS.n420 0.4505
R1024 VSS.n421 VSS.n17 0.4505
R1025 VSS.n246 VSS.n17 0.4505
R1026 VSS.n246 VSS.n245 0.4505
R1027 VSS.n245 VSS.n113 0.4505
R1028 VSS.n403 VSS.n402 0.4505
R1029 VSS.n402 VSS.n401 0.4505
R1030 VSS.n401 VSS.n26 0.4505
R1031 VSS.n115 VSS.n26 0.4505
R1032 VSS.n115 VSS.n114 0.4505
R1033 VSS.n45 VSS.n42 0.430889
R1034 VSS.n375 VSS.n374 0.430889
R1035 VSS.n375 VSS.n49 0.430889
R1036 VSS.n375 VSS.n48 0.430889
R1037 VSS.n295 VSS.n294 0.430889
R1038 VSS.n443 VSS.n424 0.430889
R1039 VSS.n440 VSS.n424 0.430889
R1040 VSS.n432 VSS.n424 0.430889
R1041 VSS.n433 VSS.n424 0.430889
R1042 VSS.n127 VSS.n121 0.430889
R1043 VSS.n137 VSS.n121 0.430889
R1044 VSS.n124 VSS.n121 0.430889
R1045 VSS.n144 VSS.n121 0.430889
R1046 VSS.n417 VSS.n19 0.430889
R1047 VSS.n414 VSS.n19 0.430889
R1048 VSS.n23 VSS.n19 0.430889
R1049 VSS.n407 VSS.n19 0.430889
R1050 VSS.n278 VSS.n105 0.430889
R1051 VSS.n278 VSS.n110 0.430889
R1052 VSS.n278 VSS.n104 0.430889
R1053 VSS.n278 VSS.n277 0.430889
R1054 VSS.n203 VSS.n19 0.430889
R1055 VSS.n208 VSS.n19 0.430889
R1056 VSS.n201 VSS.n19 0.430889
R1057 VSS.n215 VSS.n19 0.430889
R1058 VSS.n278 VSS.n106 0.430889
R1059 VSS.n278 VSS.n107 0.430889
R1060 VSS.n278 VSS.n108 0.430889
R1061 VSS.n278 VSS.n109 0.430889
R1062 VSS.n358 VSS.n0 0.37175
R1063 VSS.n200 VSS.n199 0.37175
R1064 VSS.n404 VSS.n403 0.37175
R1065 VSS.n451 VSS.n450 0.37175
R1066 VSS.n225 VSS.n179 0.366125
R1067 VSS.n218 VSS.n217 0.366125
R1068 VSS.n405 VSS.n25 0.366125
R1069 VSS.n263 VSS.n256 0.366125
R1070 VSS.n372 VSS.n57 0.3605
R1071 VSS.n57 VSS.n53 0.3155
R1072 VSS.n395 VSS.n32 0.3155
R1073 VSS.n420 VSS.n419 0.3155
R1074 VSS.n226 VSS.n225 0.309875
R1075 VSS.n218 VSS.n197 0.309875
R1076 VSS.n25 VSS.n22 0.309875
R1077 VSS.n264 VSS.n263 0.309875
R1078 VSS.n361 VSS.n0 0.28175
R1079 VSS.n451 VSS.n2 0.28175
R1080 VSS.n366 VSS.n361 0.2255
R1081 VSS.n332 VSS.n331 0.2255
R1082 VSS.n261 VSS.n260 0.189974
R1083 VSS.n223 VSS.n222 0.189974
R1084 VSS.n217 VSS.n200 0.16925
R1085 VSS.n405 VSS.n404 0.16925
R1086 VSS.n428 VSS.t39 0.1643
R1087 VSS.n428 VSS.t41 0.1643
R1088 VSS.n427 VSS.t35 0.1643
R1089 VSS.n427 VSS.t37 0.1643
R1090 VSS.n131 VSS.t47 0.1643
R1091 VSS.n131 VSS.t49 0.1643
R1092 VSS.n130 VSS.t43 0.1643
R1093 VSS.n130 VSS.t45 0.1643
R1094 VSS.n327 VSS.t101 0.1643
R1095 VSS.n327 VSS.t103 0.1643
R1096 VSS.n328 VSS.t95 0.1643
R1097 VSS.n328 VSS.t93 0.1643
R1098 VSS.n362 VSS.t91 0.1643
R1099 VSS.n362 VSS.t99 0.1643
R1100 VSS.n364 VSS.t87 0.1643
R1101 VSS.n364 VSS.t89 0.1643
R1102 VSS.n262 VSS.n257 0.1605
R1103 VSS.n224 VSS.n219 0.1605
R1104 VSS.n258 VSS.t26 0.137
R1105 VSS.n258 VSS.t24 0.137
R1106 VSS.n259 VSS.t22 0.137
R1107 VSS.n259 VSS.t19 0.137
R1108 VSS.n220 VSS.t28 0.137
R1109 VSS.n220 VSS.t29 0.137
R1110 VSS.n221 VSS.t21 0.137
R1111 VSS.n221 VSS.t27 0.137
R1112 VSS.n330 VSS.n329 0.118945
R1113 VSS.n365 VSS.n363 0.117954
R1114 VSS.n133 VSS.n129 0.113
R1115 VSS.n430 VSS.n2 0.113
R1116 VSS VSS.n453 0.0359946
R1117 a_2148_n500.n5 a_2148_n500.n3 10.5451
R1118 a_2148_n500.n5 a_2148_n500.n4 10.5451
R1119 a_2148_n500.n2 a_2148_n500.t4 6.45713
R1120 a_2148_n500.n8 a_2148_n500.n7 6.38754
R1121 a_2148_n500.n1 a_2148_n500.n0 6.29333
R1122 a_2148_n500.n6 a_2148_n500.n2 4.68405
R1123 a_2148_n500.n7 a_2148_n500.n6 2.22659
R1124 a_2148_n500.n6 a_2148_n500.n5 0.8055
R1125 a_2148_n500.n3 a_2148_n500.t1 0.3281
R1126 a_2148_n500.n3 a_2148_n500.t2 0.3281
R1127 a_2148_n500.n4 a_2148_n500.t0 0.3281
R1128 a_2148_n500.n4 a_2148_n500.t3 0.3281
R1129 a_2148_n500.n2 a_2148_n500.n1 0.189974
R1130 a_2148_n500.t7 a_2148_n500.n8 0.1643
R1131 a_2148_n500.n8 a_2148_n500.t8 0.1643
R1132 a_2148_n500.n0 a_2148_n500.t5 0.1643
R1133 a_2148_n500.n0 a_2148_n500.t6 0.1643
R1134 a_2148_n500.n7 a_2148_n500.n1 0.0928953
R1135 a_n5052_n1000.n5 a_n5052_n1000.n3 11.1933
R1136 a_n5052_n1000.n5 a_n5052_n1000.n4 11.1933
R1137 a_n5052_n1000.n2 a_n5052_n1000.t4 6.45713
R1138 a_n5052_n1000.n8 a_n5052_n1000.n7 6.38754
R1139 a_n5052_n1000.n1 a_n5052_n1000.n0 6.29333
R1140 a_n5052_n1000.n6 a_n5052_n1000.n2 4.68405
R1141 a_n5052_n1000.n7 a_n5052_n1000.n6 2.22659
R1142 a_n5052_n1000.n6 a_n5052_n1000.n5 0.5555
R1143 a_n5052_n1000.n2 a_n5052_n1000.n1 0.189974
R1144 a_n5052_n1000.t7 a_n5052_n1000.n8 0.1643
R1145 a_n5052_n1000.n8 a_n5052_n1000.t8 0.1643
R1146 a_n5052_n1000.n0 a_n5052_n1000.t5 0.1643
R1147 a_n5052_n1000.n0 a_n5052_n1000.t6 0.1643
R1148 a_n5052_n1000.n3 a_n5052_n1000.t0 0.1643
R1149 a_n5052_n1000.n3 a_n5052_n1000.t1 0.1643
R1150 a_n5052_n1000.n4 a_n5052_n1000.t3 0.1643
R1151 a_n5052_n1000.n4 a_n5052_n1000.t2 0.1643
R1152 a_n5052_n1000.n7 a_n5052_n1000.n1 0.0928953
R1153 a_n5052_2600.n3 a_n5052_2600.t7 7.27134
R1154 a_n5052_2600.n3 a_n5052_2600.t4 7.27134
R1155 a_n5052_2600.n2 a_n5052_2600.n0 6.71615
R1156 a_n5052_2600.n2 a_n5052_2600.n1 6.71615
R1157 a_n5052_2600.n4 a_n5052_2600.n3 6.31615
R1158 a_n5052_2600.n4 a_n5052_2600.t5 0.8195
R1159 a_n5052_2600.t6 a_n5052_2600.n4 0.8195
R1160 a_n5052_2600.n0 a_n5052_2600.t3 0.8195
R1161 a_n5052_2600.n0 a_n5052_2600.t2 0.8195
R1162 a_n5052_2600.n1 a_n5052_2600.t0 0.8195
R1163 a_n5052_2600.n1 a_n5052_2600.t1 0.8195
R1164 a_n5052_2600.n3 a_n5052_2600.n2 0.3955
R1165 a_5300_5958.t0 a_5300_5958.t1 26.7478
R1166 a_484_3500.t0 a_484_3500.t1 26.7478
R1167 a_n1900_5958.t1 a_n1900_5958.t0 26.7478
R1168 a_n3600_5641.n3 a_n3600_5641.t6 74.5091
R1169 a_n3600_5641.n3 a_n3600_5641.t7 74.5091
R1170 a_n3600_5641.n4 a_n3600_5641.n3 37.8057
R1171 a_n3600_5641.n1 a_n3600_5641.t1 13.0154
R1172 a_n3600_5641.n1 a_n3600_5641.t0 10.6142
R1173 a_n3600_5641.n0 a_n3600_5641.t4 7.23009
R1174 a_n3600_5641.n0 a_n3600_5641.t5 7.22685
R1175 a_n3600_5641.n5 a_n3600_5641.t2 6.55206
R1176 a_n3600_5641.t3 a_n3600_5641.n5 6.54882
R1177 a_n3600_5641.n5 a_n3600_5641.n4 2.75982
R1178 a_n3600_5641.n2 a_n3600_5641.n0 2.26891
R1179 a_n3600_5641.n2 a_n3600_5641.n1 0.425955
R1180 a_n3600_5641.n4 a_n3600_5641.n2 0.393227
R1181 a_n6572_3500.n3 a_n6572_3500.t6 74.5091
R1182 a_n6572_3500.n3 a_n6572_3500.t7 74.5091
R1183 a_n6572_3500.n4 a_n6572_3500.n3 37.5518
R1184 a_n6572_3500.n1 a_n6572_3500.t1 13.0154
R1185 a_n6572_3500.n1 a_n6572_3500.t0 10.6142
R1186 a_n6572_3500.n0 a_n6572_3500.t3 7.23009
R1187 a_n6572_3500.n0 a_n6572_3500.t2 7.22685
R1188 a_n6572_3500.t5 a_n6572_3500.n5 6.55206
R1189 a_n6572_3500.n5 a_n6572_3500.t4 6.54882
R1190 a_n6572_3500.n5 a_n6572_3500.n4 2.59618
R1191 a_n6572_3500.n2 a_n6572_3500.n0 2.26891
R1192 a_n6572_3500.n4 a_n6572_3500.n2 0.556864
R1193 a_n6572_3500.n2 a_n6572_3500.n1 0.425955
R1194 a_n6716_3500.t0 a_n6716_3500.t1 26.7478
R1195 a_n852_19400.n5 a_n852_19400.n3 10.7042
R1196 a_n852_19400.n5 a_n852_19400.n4 10.7042
R1197 a_n852_19400.t5 a_n852_19400.n7 6.77
R1198 a_n852_19400.n2 a_n852_19400.t2 6.6753
R1199 a_n852_19400.n1 a_n852_19400.n0 6.5388
R1200 a_n852_19400.n6 a_n852_19400.n2 4.63668
R1201 a_n852_19400.n7 a_n852_19400.n6 2.23814
R1202 a_n852_19400.n6 a_n852_19400.n5 0.5055
R1203 a_n852_19400.n2 a_n852_19400.n1 0.189974
R1204 a_n852_19400.n3 a_n852_19400.t0 0.1643
R1205 a_n852_19400.n3 a_n852_19400.t1 0.1643
R1206 a_n852_19400.n4 a_n852_19400.t7 0.1643
R1207 a_n852_19400.n4 a_n852_19400.t6 0.1643
R1208 a_n852_19400.n0 a_n852_19400.t3 0.137
R1209 a_n852_19400.n0 a_n852_19400.t4 0.137
R1210 a_n852_19400.n7 a_n852_19400.n1 0.0924286
R1211 a_n852_28800.n5 a_n852_28800.n3 10.7042
R1212 a_n852_28800.n5 a_n852_28800.n4 10.7042
R1213 a_n852_28800.t6 a_n852_28800.n7 6.77
R1214 a_n852_28800.n2 a_n852_28800.t3 6.6753
R1215 a_n852_28800.n1 a_n852_28800.n0 6.5388
R1216 a_n852_28800.n6 a_n852_28800.n2 4.63668
R1217 a_n852_28800.n7 a_n852_28800.n6 2.23814
R1218 a_n852_28800.n6 a_n852_28800.n5 0.5055
R1219 a_n852_28800.n2 a_n852_28800.n1 0.189974
R1220 a_n852_28800.n3 a_n852_28800.t7 0.1643
R1221 a_n852_28800.n3 a_n852_28800.t0 0.1643
R1222 a_n852_28800.n4 a_n852_28800.t2 0.1643
R1223 a_n852_28800.n4 a_n852_28800.t1 0.1643
R1224 a_n852_28800.n0 a_n852_28800.t4 0.137
R1225 a_n852_28800.n0 a_n852_28800.t5 0.137
R1226 a_n852_28800.n7 a_n852_28800.n1 0.0924286
R1227 a_600_22678.n0 a_600_22678.t4 139.689
R1228 a_600_22678.n0 a_600_22678.t3 139.689
R1229 a_600_22678.n1 a_600_22678.n0 37.2961
R1230 a_600_22678.n1 a_600_22678.t0 12.557
R1231 a_600_22678.n2 a_600_22678.t1 6.0613
R1232 a_600_22678.t2 a_600_22678.n2 6.0613
R1233 a_600_22678.n2 a_600_22678.n1 2.78832
R1234 a_n1000_22678.n0 a_n1000_22678.t4 139.689
R1235 a_n1000_22678.n0 a_n1000_22678.t3 139.689
R1236 a_n1000_22678.n1 a_n1000_22678.n0 37.2961
R1237 a_n1000_22678.n1 a_n1000_22678.t0 12.557
R1238 a_n1000_22678.n2 a_n1000_22678.t1 6.0613
R1239 a_n1000_22678.t2 a_n1000_22678.n2 6.0613
R1240 a_n1000_22678.n2 a_n1000_22678.n1 2.78832
R1241 a_11748_41600.n5 a_11748_41600.n3 10.7791
R1242 a_11748_41600.n5 a_11748_41600.n4 10.7791
R1243 a_11748_41600.t5 a_11748_41600.n7 6.55182
R1244 a_11748_41600.n2 a_11748_41600.t2 6.45713
R1245 a_11748_41600.n1 a_11748_41600.n0 6.29333
R1246 a_11748_41600.n6 a_11748_41600.n2 4.63668
R1247 a_11748_41600.n7 a_11748_41600.n6 2.23814
R1248 a_11748_41600.n6 a_11748_41600.n5 0.3305
R1249 a_11748_41600.n3 a_11748_41600.t1 0.20525
R1250 a_11748_41600.n3 a_11748_41600.t0 0.20525
R1251 a_11748_41600.n4 a_11748_41600.t6 0.20525
R1252 a_11748_41600.n4 a_11748_41600.t7 0.20525
R1253 a_11748_41600.n2 a_11748_41600.n1 0.189974
R1254 a_11748_41600.n0 a_11748_41600.t3 0.1643
R1255 a_11748_41600.n0 a_11748_41600.t4 0.1643
R1256 a_11748_41600.n7 a_11748_41600.n1 0.0924286
R1257 a_2148_41600.n5 a_2148_41600.n3 10.7791
R1258 a_2148_41600.n5 a_2148_41600.n4 10.7791
R1259 a_2148_41600.t5 a_2148_41600.n7 6.55182
R1260 a_2148_41600.n2 a_2148_41600.t2 6.45713
R1261 a_2148_41600.n1 a_2148_41600.n0 6.29333
R1262 a_2148_41600.n6 a_2148_41600.n2 4.63668
R1263 a_2148_41600.n7 a_2148_41600.n6 2.23814
R1264 a_2148_41600.n6 a_2148_41600.n5 0.3305
R1265 a_2148_41600.n3 a_2148_41600.t7 0.20525
R1266 a_2148_41600.n3 a_2148_41600.t6 0.20525
R1267 a_2148_41600.n4 a_2148_41600.t0 0.20525
R1268 a_2148_41600.n4 a_2148_41600.t1 0.20525
R1269 a_2148_41600.n2 a_2148_41600.n1 0.189974
R1270 a_2148_41600.n0 a_2148_41600.t3 0.1643
R1271 a_2148_41600.n0 a_2148_41600.t4 0.1643
R1272 a_2148_41600.n7 a_2148_41600.n1 0.0924286
R1273 a_12148_44200.n2 a_12148_44200.n0 15.3662
R1274 a_12148_44200.n2 a_12148_44200.n1 14.5662
R1275 a_12148_44200.n3 a_12148_44200.n2 7.70696
R1276 a_12148_44200.n3 a_12148_44200.t5 5.9772
R1277 a_12148_44200.t4 a_12148_44200.n3 5.9772
R1278 a_12148_44200.n0 a_12148_44200.t1 0.2735
R1279 a_12148_44200.n0 a_12148_44200.t0 0.2735
R1280 a_12148_44200.n1 a_12148_44200.t3 0.2735
R1281 a_12148_44200.n1 a_12148_44200.t2 0.2735
R1282 a_10548_44200.n2 a_10548_44200.n0 19.8662
R1283 a_10548_44200.n2 a_10548_44200.n1 19.3329
R1284 a_10548_44200.n3 a_10548_44200.n2 11.5875
R1285 a_10548_44200.n3 a_10548_44200.t2 5.9772
R1286 a_10548_44200.t3 a_10548_44200.n3 5.9772
R1287 a_10548_44200.n1 a_10548_44200.t5 0.2735
R1288 a_10548_44200.n1 a_10548_44200.t4 0.2735
R1289 a_10548_44200.n0 a_10548_44200.t1 0.2735
R1290 a_10548_44200.n0 a_10548_44200.t0 0.2735
R1291 a_2548_44200.n2 a_2548_44200.n0 15.3662
R1292 a_2548_44200.n2 a_2548_44200.n1 14.5662
R1293 a_2548_44200.n3 a_2548_44200.n2 7.70696
R1294 a_2548_44200.n3 a_2548_44200.t5 5.9772
R1295 a_2548_44200.t4 a_2548_44200.n3 5.9772
R1296 a_2548_44200.n0 a_2548_44200.t3 0.2735
R1297 a_2548_44200.n0 a_2548_44200.t2 0.2735
R1298 a_2548_44200.n1 a_2548_44200.t1 0.2735
R1299 a_2548_44200.n1 a_2548_44200.t0 0.2735
R1300 a_948_44200.n2 a_948_44200.n0 19.8662
R1301 a_948_44200.n2 a_948_44200.n1 19.3329
R1302 a_948_44200.n3 a_948_44200.n2 11.5875
R1303 a_948_44200.n3 a_948_44200.t0 5.9772
R1304 a_948_44200.t1 a_948_44200.n3 5.9772
R1305 a_948_44200.n1 a_948_44200.t5 0.2735
R1306 a_948_44200.n1 a_948_44200.t4 0.2735
R1307 a_948_44200.n0 a_948_44200.t3 0.2735
R1308 a_948_44200.n0 a_948_44200.t2 0.2735
C0 VDD ODD_P 0.35499f
C1 EVEN_P RX_RESTN 0.42621f
C2 ODD_N RX_RESTN 0.01966f
C3 SAMP_CLK_N RX_RESTN 0.09294f
C4 RX_RESTP SAMP_CLK_P 0.38527f
C5 REST_BIAS RX_RAWN 0.11711f
C6 ODD_P ODD_N 1.05177f
C7 RX_RESTP RX_RESTN 4.19071f
C8 VDD REST_BIAS 0.20996f
C9 RX_RESTP ODD_P 0.10098f
C10 VDD VTHN 0.51765f
C11 ODD_P RX_RESTN 0.17429f
C12 VTHP VDD 0.93005f
C13 RXN RXP 0.26804f
C14 SAMP_CLK_N SAMP_BIAS 1.47664f
C15 RX_RAWP REST_BIAS 0.25868f
C16 RX_BW_EN_N VTHN 0.52758f
C17 VTHP RX_BW_EN_N 0.14804f
C18 RX_BIAS RXN 0.36034f
C19 RX_BIAS RXP 0.89265f
C20 SAMP_CLK_P SAMP_BIAS 2.0425f
C21 SAMP_BIAS RX_RESTN 0.01215f
C22 VDD EVEN_N 0.26142f
C23 VDD RX_RAWN 1.26797f
C24 EVEN_P EVEN_N 0.97809f
C25 RX_BW_EN_N RX_RAWN 0.3734f
C26 RX_RESTP EVEN_N 0.17266f
C27 VDD EVEN_P 0.26142f
C28 RX_RAWP RX_RAWN 0.58235f
C29 VDD ODD_N 0.35499f
C30 RX_BW_EN_N VDD 3.19847f
C31 RX_RESTN EVEN_N 0.21698f
C32 VTHP VTHN 1.695f
C33 RX_RESTP VDD 0.38423f
C34 RX_RAWP VDD 1.26797f
C35 RX_RESTP EVEN_P 0.05468f
C36 RX_RESTP ODD_N 0.21629f
C37 RX_RESTP SAMP_CLK_N 0.02351f
C38 RX_BW_EN_N RX_RAWP 0.3734f
C39 SAMP_CLK_P SAMP_CLK_N 2.34225f
C40 VDD RX_RESTN 0.41275f
C41 RXN VSS 3.72355f
C42 RXP VSS 4.1711f
C43 RX_BIAS VSS 13.33431f
C44 VTHN VSS 5.17466f
C45 VTHP VSS 5.04058f
C46 RX_BW_EN_N VSS 4.30524f
C47 RX_RAWN VSS 11.07534f
C48 RX_RAWP VSS 11.20287f
C49 REST_BIAS VSS 10.07665f
C50 SAMP_BIAS VSS 13.87178f
C51 SAMP_CLK_N VSS 9.98147f
C52 SAMP_CLK_P VSS 14.21055f
C53 RX_RESTP VSS 14.02047f
C54 RX_RESTN VSS 13.0766f
C55 ODD_N VSS 8.66315f
C56 ODD_P VSS 8.80528f
C57 EVEN_N VSS 8.57085f
C58 EVEN_P VSS 8.67124f
C59 VDD VSS 0.13693p
C60 a_948_44200.t0 VSS 0.63799f
C61 a_948_44200.t3 VSS 0.1331f
C62 a_948_44200.t2 VSS 0.1331f
C63 a_948_44200.n0 VSS 0.51748f
C64 a_948_44200.t5 VSS 0.13204f
C65 a_948_44200.t4 VSS 0.13204f
C66 a_948_44200.n1 VSS 0.47973f
C67 a_948_44200.n2 VSS 3.66241f
C68 a_948_44200.n3 VSS 0.50661f
C69 a_948_44200.t1 VSS 0.63799f
C70 a_2548_44200.t5 VSS 0.84552f
C71 a_2548_44200.t3 VSS 0.15819f
C72 a_2548_44200.t2 VSS 0.15819f
C73 a_2548_44200.n0 VSS 0.62947f
C74 a_2548_44200.t1 VSS 0.15955f
C75 a_2548_44200.t0 VSS 0.15955f
C76 a_2548_44200.n1 VSS 0.59103f
C77 a_2548_44200.n2 VSS 2.81846f
C78 a_2548_44200.n3 VSS 0.69295f
C79 a_2548_44200.t4 VSS 0.84552f
C80 a_10548_44200.t2 VSS 0.61673f
C81 a_10548_44200.t1 VSS 0.13032f
C82 a_10548_44200.t0 VSS 0.13032f
C83 a_10548_44200.n0 VSS 0.50161f
C84 a_10548_44200.t5 VSS 0.12927f
C85 a_10548_44200.t4 VSS 0.12927f
C86 a_10548_44200.n1 VSS 0.46501f
C87 a_10548_44200.n2 VSS 3.55006f
C88 a_10548_44200.n3 VSS 0.49107f
C89 a_10548_44200.t3 VSS 0.61673f
C90 a_12148_44200.t5 VSS 0.83953f
C91 a_12148_44200.t1 VSS 0.15776f
C92 a_12148_44200.t0 VSS 0.15776f
C93 a_12148_44200.n0 VSS 0.62265f
C94 a_12148_44200.t3 VSS 0.1572f
C95 a_12148_44200.t2 VSS 0.1572f
C96 a_12148_44200.n1 VSS 0.58462f
C97 a_12148_44200.n2 VSS 2.78788f
C98 a_12148_44200.n3 VSS 0.68544f
C99 a_12148_44200.t4 VSS 0.83953f
C100 a_2148_41600.t4 VSS 0.1448f
C101 a_2148_41600.t3 VSS 0.1448f
C102 a_2148_41600.n0 VSS 0.41454f
C103 a_2148_41600.n1 VSS 0.13505f
C104 a_2148_41600.t2 VSS 0.59158f
C105 a_2148_41600.n2 VSS 0.12082f
C106 a_2148_41600.t6 VSS 0.1243f
C107 a_2148_41600.t7 VSS 0.1243f
C108 a_2148_41600.n3 VSS 0.38577f
C109 a_2148_41600.t1 VSS 0.12712f
C110 a_2148_41600.t0 VSS 0.12712f
C111 a_2148_41600.n4 VSS 0.38577f
C112 a_2148_41600.n5 VSS 1.18313f
C113 a_2148_41600.n6 VSS 0.35665f
C114 a_2148_41600.n7 VSS 0.11907f
C115 a_2148_41600.t5 VSS 0.59332f
C116 a_11748_41600.t4 VSS 0.14207f
C117 a_11748_41600.t3 VSS 0.14207f
C118 a_11748_41600.n0 VSS 0.40451f
C119 a_11748_41600.n1 VSS 0.13178f
C120 a_11748_41600.t2 VSS 0.57804f
C121 a_11748_41600.n2 VSS 0.1179f
C122 a_11748_41600.t0 VSS 0.12494f
C123 a_11748_41600.t1 VSS 0.12494f
C124 a_11748_41600.n3 VSS 0.37643f
C125 a_11748_41600.t7 VSS 0.12212f
C126 a_11748_41600.t6 VSS 0.12212f
C127 a_11748_41600.n4 VSS 0.37643f
C128 a_11748_41600.n5 VSS 1.15448f
C129 a_11748_41600.n6 VSS 0.34802f
C130 a_11748_41600.n7 VSS 0.11619f
C131 a_11748_41600.t5 VSS 0.57975f
C132 a_n1000_22678.t1 VSS 0.43066f
C133 a_n1000_22678.t0 VSS 0.11274f
C134 a_n1000_22678.n0 VSS 0.61981f
C135 a_n1000_22678.n1 VSS 1.98011f
C136 a_n1000_22678.n2 VSS 0.20692f
C137 a_n1000_22678.t2 VSS 0.43066f
C138 a_600_22678.t1 VSS 0.47347f
C139 a_600_22678.t0 VSS 0.12618f
C140 a_600_22678.n0 VSS 0.69373f
C141 a_600_22678.n1 VSS 2.21625f
C142 a_600_22678.n2 VSS 0.23159f
C143 a_600_22678.t2 VSS 0.47347f
C144 a_n852_28800.t5 VSS 0.17014f
C145 a_n852_28800.t4 VSS 0.17014f
C146 a_n852_28800.n0 VSS 0.49564f
C147 a_n852_28800.n1 VSS 0.14146f
C148 a_n852_28800.t3 VSS 0.70725f
C149 a_n852_28800.n2 VSS 0.12671f
C150 a_n852_28800.t0 VSS 0.18675f
C151 a_n852_28800.t7 VSS 0.18675f
C152 a_n852_28800.n3 VSS 0.46111f
C153 a_n852_28800.t1 VSS 0.17892f
C154 a_n852_28800.t2 VSS 0.17892f
C155 a_n852_28800.n4 VSS 0.46111f
C156 a_n852_28800.n5 VSS 0.96575f
C157 a_n852_28800.n6 VSS 0.42664f
C158 a_n852_28800.n7 VSS 0.12494f
C159 a_n852_28800.t6 VSS 0.70902f
C160 a_n852_19400.t4 VSS 0.18447f
C161 a_n852_19400.t3 VSS 0.18447f
C162 a_n852_19400.n0 VSS 0.5479f
C163 a_n852_19400.n1 VSS 0.15638f
C164 a_n852_19400.t2 VSS 0.77818f
C165 a_n852_19400.n2 VSS 0.14008f
C166 a_n852_19400.t1 VSS 0.16971f
C167 a_n852_19400.t0 VSS 0.16971f
C168 a_n852_19400.n3 VSS 0.50974f
C169 a_n852_19400.t6 VSS 0.17261f
C170 a_n852_19400.t7 VSS 0.17261f
C171 a_n852_19400.n4 VSS 0.50974f
C172 a_n852_19400.n5 VSS 1.06759f
C173 a_n852_19400.n6 VSS 0.47163f
C174 a_n852_19400.n7 VSS 0.13812f
C175 a_n852_19400.t5 VSS 0.78013f
C176 a_n6716_3500.t1 VSS 0.543f
C177 a_n6716_3500.t0 VSS 1.11245f
C178 a_n6572_3500.t4 VSS 0.53704f
C179 a_n6572_3500.t2 VSS 0.11763f
C180 a_n6572_3500.t3 VSS 0.11768f
C181 a_n6572_3500.n0 VSS 0.18549f
C182 a_n6572_3500.t0 VSS 0.36985f
C183 a_n6572_3500.t1 VSS 0.15622f
C184 a_n6572_3500.n1 VSS 1.39633f
C185 a_n6572_3500.n2 VSS 0.64607f
C186 a_n6572_3500.n3 VSS 0.84861f
C187 a_n6572_3500.n4 VSS 2.74162f
C188 a_n6572_3500.n5 VSS 0.25248f
C189 a_n6572_3500.t5 VSS 0.53713f
C190 a_n3600_5641.t2 VSS 0.51582f
C191 a_n3600_5641.t4 VSS 0.11508f
C192 a_n3600_5641.t5 VSS 0.11503f
C193 a_n3600_5641.n0 VSS 0.18273f
C194 a_n3600_5641.t0 VSS 0.3653f
C195 a_n3600_5641.t1 VSS 0.1539f
C196 a_n3600_5641.n1 VSS 1.37555f
C197 a_n3600_5641.n2 VSS 0.55474f
C198 a_n3600_5641.n3 VSS 1.07214f
C199 a_n3600_5641.n4 VSS 2.44613f
C200 a_n3600_5641.n5 VSS 0.28121f
C201 a_n3600_5641.t3 VSS 0.51573f
C202 a_n1900_5958.t0 VSS 0.5683f
C203 a_n1900_5958.t1 VSS 1.16128f
C204 a_484_3500.t1 VSS 0.57067f
C205 a_484_3500.t0 VSS 1.16586f
C206 a_5300_5958.t1 VSS 0.53942f
C207 a_5300_5958.t0 VSS 1.11788f
C208 a_n5052_2600.t5 VSS 0.0301f
C209 a_n5052_2600.t7 VSS 0.12118f
C210 a_n5052_2600.t4 VSS 0.12118f
C211 a_n5052_2600.t2 VSS 0.04306f
C212 a_n5052_2600.t3 VSS 0.04303f
C213 a_n5052_2600.n0 VSS 0.10737f
C214 a_n5052_2600.t1 VSS 0.04419f
C215 a_n5052_2600.t0 VSS 0.04422f
C216 a_n5052_2600.n1 VSS 0.10737f
C217 a_n5052_2600.n2 VSS 0.98516f
C218 a_n5052_2600.n3 VSS 0.46257f
C219 a_n5052_2600.n4 VSS 0.09122f
C220 a_n5052_2600.t6 VSS 0.0301f
C221 a_n5052_n1000.t8 VSS 0.156f
C222 a_n5052_n1000.t6 VSS 0.15555f
C223 a_n5052_n1000.t5 VSS 0.15555f
C224 a_n5052_n1000.n0 VSS 0.45893f
C225 a_n5052_n1000.n1 VSS 0.14951f
C226 a_n5052_n1000.t4 VSS 0.6501f
C227 a_n5052_n1000.n2 VSS 0.13501f
C228 a_n5052_n1000.t1 VSS 0.16053f
C229 a_n5052_n1000.t0 VSS 0.16053f
C230 a_n5052_n1000.n3 VSS 0.50742f
C231 a_n5052_n1000.t2 VSS 0.17458f
C232 a_n5052_n1000.t3 VSS 0.17458f
C233 a_n5052_n1000.n4 VSS 0.50742f
C234 a_n5052_n1000.n5 VSS 1.21852f
C235 a_n5052_n1000.n6 VSS 0.49183f
C236 a_n5052_n1000.n7 VSS 0.11815f
C237 a_n5052_n1000.n8 VSS 0.4607f
C238 a_n5052_n1000.t7 VSS 0.15555f
C239 a_2148_n500.t8 VSS 0.1091f
C240 a_2148_n500.t6 VSS 0.10865f
C241 a_2148_n500.t5 VSS 0.10865f
C242 a_2148_n500.n0 VSS 0.28658f
C243 a_2148_n500.n1 VSS 0.09336f
C244 a_2148_n500.t4 VSS 0.41764f
C245 a_2148_n500.n2 VSS 0.08431f
C246 a_2148_n500.t2 VSS 0.08272f
C247 a_2148_n500.t1 VSS 0.08272f
C248 a_2148_n500.n3 VSS 0.17591f
C249 a_2148_n500.t3 VSS 0.08338f
C250 a_2148_n500.t0 VSS 0.08338f
C251 a_2148_n500.n4 VSS 0.17591f
C252 a_2148_n500.n5 VSS 0.81634f
C253 a_2148_n500.n6 VSS 0.37461f
C254 a_2148_n500.n7 VSS 0.07378f
C255 a_2148_n500.n8 VSS 0.28768f
C256 a_2148_n500.t7 VSS 0.10865f
C257 VSS.t45 VSS 0.03199f
C258 VSS.t43 VSS 0.03245f
C259 VSS.t49 VSS 0.03245f
C260 VSS.t47 VSS 0.03199f
C261 VSS.t29 VSS 0.03465f
C262 VSS.t28 VSS 0.03424f
C263 VSS.t27 VSS 0.03424f
C264 VSS.t21 VSS 0.03465f
C265 VSS.t24 VSS 0.03465f
C266 VSS.t26 VSS 0.03424f
C267 VSS.t19 VSS 0.03424f
C268 VSS.t22 VSS 0.03465f
C269 VSS.t105 VSS 0.03111f
C270 VSS.t103 VSS 0.03066f
C271 VSS.t101 VSS 0.03066f
C272 VSS.t93 VSS 0.03066f
C273 VSS.t95 VSS 0.03111f
C274 VSS.t99 VSS 0.03066f
C275 VSS.t91 VSS 0.03066f
C276 VSS.t97 VSS 0.03111f
C277 VSS.t89 VSS 0.03066f
C278 VSS.t87 VSS 0.03111f
C279 VSS.t37 VSS 0.03199f
C280 VSS.t35 VSS 0.03245f
C281 VSS.t41 VSS 0.03245f
C282 VSS.t39 VSS 0.03199f
C283 VDD.t8 VSS 0.031f
C284 VDD.t18 VSS 0.02643f
C285 VDD.n0 VSS 0.30545f
C286 VDD.t11 VSS 0.02643f
C287 VDD.n1 VSS 0.33051f
C288 VDD.t12 VSS 0.02643f
C289 VDD.n2 VSS 0.39946f
C290 VDD.t1 VSS 0.85902f
C291 VDD.t2 VSS 1.03082f
C292 VDD.t3 VSS 1.03082f
C293 VDD.t4 VSS 0.78921f
C294 VDD.t17 VSS 0.01867f
C295 VDD.t9 VSS 0.02059f
C296 VDD.n3 VSS 0.12365f
C297 VDD.t15 VSS 0.02059f
C298 VDD.n4 VSS 0.06311f
C299 VDD.t0 VSS 0.0178f
C300 VDD.n5 VSS 0.07989f
C301 VDD.t14 VSS 0.0178f
C302 VDD.n6 VSS 0.13592f
C303 VDD.t10 VSS 0.02206f
C304 VDD.n7 VSS 0.11898f
C305 VDD.t19 VSS 0.02206f
C306 VDD.n8 VSS 0.11898f
C307 VDD.t16 VSS 0.0178f
C308 VDD.n9 VSS 0.09369f
C309 VDD.n10 VSS 1.77754f
C310 VDD.t7 VSS 0.02733f
C311 VDD.t6 VSS 0.02602f
C312 VDD.n11 VSS 0.28227f
C313 VDD.t5 VSS 0.02733f
C314 VDD.t13 VSS 0.02602f
C315 VDD.n12 VSS 0.13987f
C316 VDD.n13 VSS 0.84473f
C317 VDD.n14 VSS 4.83776f
C318 EVEN_P.t0 VSS 0.10167f
C319 EVEN_P.n0 VSS 0.28196f
C320 EVEN_P.n1 VSS 0.68195f
C321 EVEN_P.n2 VSS 0.06693f
C322 EVEN_P.t2 VSS 0.24588f
C323 EVEN_P.n3 VSS 0.06857f
C324 EVEN_P.t1 VSS 0.24588f
C325 EVEN_P.n4 VSS 0.06857f
C326 EVEN_P.n5 VSS 0.05829f
C327 EVEN_P.n6 VSS 0.21415f
C328 EVEN_P.t3 VSS 0.25249f
C329 EVEN_P.t4 VSS 0.25242f
C330 EVEN_P.n7 VSS 0.15864f
C331 EVEN_P.n8 VSS 0.50341f
C332 EVEN_P.n9 VSS 0.83448f
C333 EVEN_N.t4 VSS 0.09797f
C334 EVEN_N.t2 VSS 0.24582f
C335 EVEN_N.t3 VSS 0.24588f
C336 EVEN_N.n0 VSS 0.15287f
C337 EVEN_N.n1 VSS 0.19452f
C338 EVEN_N.n2 VSS 0.64927f
C339 EVEN_N.n3 VSS 0.04701f
C340 EVEN_N.t1 VSS 0.23963f
C341 EVEN_N.t0 VSS 0.23963f
C342 EVEN_N.n4 VSS 0.06607f
C343 EVEN_N.n5 VSS 0.06607f
C344 EVEN_N.n6 VSS 0.05618f
C345 EVEN_N.n7 VSS 0.20637f
C346 EVEN_N.n8 VSS 0.48511f
C347 EVEN_N.n9 VSS 0.80416f
C348 ODD_P.t2 VSS 0.09888f
C349 ODD_P.n0 VSS 0.25584f
C350 ODD_P.n1 VSS 0.71196f
C351 ODD_P.n2 VSS 0.04744f
C352 ODD_P.t1 VSS 0.24103f
C353 ODD_P.n3 VSS 0.06669f
C354 ODD_P.t0 VSS 0.24103f
C355 ODD_P.n4 VSS 0.06669f
C356 ODD_P.n5 VSS 0.0567f
C357 ODD_P.n6 VSS 0.20828f
C358 ODD_P.t3 VSS 0.24672f
C359 ODD_P.t4 VSS 0.24665f
C360 ODD_P.n7 VSS 0.15429f
C361 ODD_P.n8 VSS 0.48961f
C362 ODD_P.n9 VSS 0.81162f
C363 ODD_N.t4 VSS 0.10039f
C364 ODD_N.t3 VSS 0.25083f
C365 ODD_N.t2 VSS 0.2509f
C366 ODD_N.n0 VSS 0.15664f
C367 ODD_N.n1 VSS 0.21139f
C368 ODD_N.n2 VSS 0.62245f
C369 ODD_N.n3 VSS 0.06609f
C370 ODD_N.t1 VSS 0.24358f
C371 ODD_N.t0 VSS 0.24358f
C372 ODD_N.n4 VSS 0.0677f
C373 ODD_N.n5 VSS 0.0677f
C374 ODD_N.n6 VSS 0.05756f
C375 ODD_N.n7 VSS 0.21146f
C376 ODD_N.n8 VSS 0.49708f
C377 ODD_N.n9 VSS 0.824f
C378 RX_RESTN.n0 VSS 0.13623f
C379 RX_RESTN.n1 VSS 0.47066f
C380 RX_RESTN.n2 VSS 2.92409f
C381 RX_RESTN.t2 VSS 0.11488f
C382 RX_RESTN.t1 VSS 0.46315f
C383 RX_RESTN.t0 VSS 0.46315f
C384 RX_RESTN.n3 VSS 0.20876f
C385 RX_RESTN.n4 VSS 1.09392f
C386 RX_RESTP.n0 VSS 0.46983f
C387 RX_RESTP.n1 VSS 0.21633f
C388 RX_RESTP.n2 VSS 3.88442f
C389 RX_RESTP.t1 VSS 0.11779f
C390 RX_RESTP.t2 VSS 0.46518f
C391 RX_RESTP.t0 VSS 0.46518f
C392 RX_RESTP.n3 VSS 0.21405f
C393 RX_RESTP.n4 VSS 1.08937f
C394 SAMP_CLK_P.n0 VSS 0.13015f
C395 SAMP_CLK_P.n1 VSS 0.25013f
C396 SAMP_CLK_P.n2 VSS 3.73964f
C397 SAMP_CLK_N.n0 VSS 0.10938f
C398 SAMP_CLK_N.n1 VSS 0.22229f
C399 SAMP_CLK_N.n2 VSS 2.93308f
C400 SAMP_BIAS.n0 VSS 0.02864f
C401 SAMP_BIAS.n1 VSS 0.03072f
C402 SAMP_BIAS.n2 VSS 0.03072f
C403 SAMP_BIAS.n3 VSS 0.02864f
C404 SAMP_BIAS.n4 VSS 0.25264f
C405 SAMP_BIAS.n5 VSS 0.02864f
C406 SAMP_BIAS.n6 VSS 0.03072f
C407 SAMP_BIAS.n7 VSS 0.03072f
C408 SAMP_BIAS.n8 VSS 0.02864f
C409 SAMP_BIAS.n9 VSS 0.08713f
C410 SAMP_BIAS.n10 VSS 2.16477f
C411 REST_BIAS.n0 VSS 0.02944f
C412 REST_BIAS.n1 VSS 0.03128f
C413 REST_BIAS.n2 VSS 0.03128f
C414 REST_BIAS.n3 VSS 0.02944f
C415 REST_BIAS.n4 VSS 0.22195f
C416 REST_BIAS.n5 VSS 0.02944f
C417 REST_BIAS.n6 VSS 0.03128f
C418 REST_BIAS.n7 VSS 0.03128f
C419 REST_BIAS.n8 VSS 0.02944f
C420 REST_BIAS.n9 VSS 0.07827f
C421 REST_BIAS.n10 VSS 1.38426f
C422 RX_RAWP.n0 VSS 0.50786f
C423 RX_RAWP.t3 VSS 0.07485f
C424 RX_RAWP.t0 VSS 0.23743f
C425 RX_RAWP.t1 VSS 0.18226f
C426 RX_RAWP.t2 VSS 0.18231f
C427 RX_RAWP.n1 VSS 0.32417f
C428 RX_RAWP.n2 VSS 1.0692f
C429 RX_RAWP.n3 VSS 0.45242f
C430 RX_RAWN.n0 VSS 0.47865f
C431 RX_RAWN.t3 VSS 0.07027f
C432 RX_RAWN.t0 VSS 0.23918f
C433 RX_RAWN.t1 VSS 0.17321f
C434 RX_RAWN.t2 VSS 0.17316f
C435 RX_RAWN.n1 VSS 0.30433f
C436 RX_RAWN.n2 VSS 1.00377f
C437 RX_RAWN.n3 VSS 0.42473f
C438 RX_BW_EN_N.n0 VSS 2.37285f
C439 RX_BW_EN_N.n1 VSS 1.30569f
C440 RX_BW_EN_N.n2 VSS 1.47388f
C441 VTHP.n0 VSS 0.61322f
C442 VTHN.n0 VSS 0.63951f
C443 RX_BIAS.n0 VSS 0.02774f
C444 RX_BIAS.n1 VSS 0.02945f
C445 RX_BIAS.n2 VSS 0.02945f
C446 RX_BIAS.n3 VSS 0.02945f
C447 RX_BIAS.n4 VSS 0.02774f
C448 RX_BIAS.n5 VSS 0.1188f
C449 RX_BIAS.n6 VSS 0.01105f
C450 RX_BIAS.n7 VSS 0.01374f
C451 RX_BIAS.n8 VSS 0.01374f
C452 RX_BIAS.n9 VSS 0.01105f
C453 RX_BIAS.n10 VSS 0.27429f
C454 RX_BIAS.n11 VSS 0.02774f
C455 RX_BIAS.n12 VSS 0.02945f
C456 RX_BIAS.n13 VSS 0.02945f
C457 RX_BIAS.n14 VSS 0.02945f
C458 RX_BIAS.n15 VSS 0.02774f
C459 RX_BIAS.n16 VSS 0.1076f
C460 RX_BIAS.n17 VSS 0.72427f
C461 RX_BIAS.n18 VSS 0.71169f
C462 RXP.n0 VSS 0.27985f
C463 RXN.n0 VSS 0.2007f
.ends
