* SPDX-License-Identifier: Apache-2.0
* Differential CML limiting stage for the weak-corner VCO/divider boundary.
.subckt cml_clock_restorer IN_P IN_N VBIAS VDD VSS OUT_P OUT_N
+ params: LOAD_L=7.5u
XRP VDD OUT_P VSS ppolyf_u r_width=2u r_length={LOAD_L}
XRN VDD OUT_N VSS ppolyf_u r_width=2u r_length={LOAD_L}
XIP OUT_P IN_P NTAIL VSS nfet_03v3 w=10u l=0.28u m=2
XIN OUT_N IN_N NTAIL VSS nfet_03v3 w=10u l=0.28u m=2
XTAIL NTAIL VBIAS VSS VSS nfet_03v3 w=12u l=0.28u m=4
.ends cml_clock_restorer
