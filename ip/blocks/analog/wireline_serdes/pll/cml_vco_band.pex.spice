* PEX produced on Wed Aug 19 11:44:08 AM CEST 2026 using /foss/tools/sak/sak-pex.sh with m=3 and s=1 (extresist threshold=0 mOhm, minres=1 mOhm, mindelay=0 ps)
* NGSPICE file created from cml_vco_band_pex.ext - technology: gf180mcuD

.subckt cml_vco_band_pex VCTRL KICKP KICKN VDD VSS CLK_P CLK_N
X0 VDD.t1 XSTART.NODEN.t0 VSS.t5 ppolyf_u r_width=2u r_length=4u
X1 VSS.t32 CLK_N.t5 VSS.t31 VSS.t17 nfet_03v3 ad=1.408p pd=7.28u as=0 ps=0 w=3.2u l=0.37u
X2 XSTART.NODEP.t2 XBUF.INP.t8 a_n3052_n500.t3 VSS.t40 nfet_03v3 ad=2.2p pd=10.88u as=1.3p ps=5.52u w=5u l=0.28u
X3 VSS.t60 VCTRL.t17 a_10948_n500.t2 VSS.t59 nfet_03v3 ad=3.9p pd=15.52u as=6.6p ps=30.88u w=15u l=0.28u
X4 VDD.t6 XBUF.INN.t3 VSS.t12 ppolyf_u r_width=2u r_length=4u
X5 a_n3052_n500.t1 XBUF.INN.t9 XSTART.NODEN.t2 VSS.t35 nfet_03v3 ad=1.3p pd=5.52u as=2.2p ps=10.88u w=5u l=0.28u
X6 VSS.t58 VCTRL.t19 a_n972_n400.t1 VSS.t57 nfet_03v3 ad=1.56p pd=6.52u as=2.64p ps=12.88u w=6u l=0.28u
X7 VDD.t2 X2.INP.t2 VSS.t16 ppolyf_u r_width=2u r_length=4u
X8 a_10948_n500.t5 VCTRL.t14 VSS.t70 VSS.t69 nfet_03v3 ad=6.6p pd=30.88u as=3.9p ps=15.52u w=15u l=0.28u
X9 VSS.t29 XBUF.INP.t7 VSS.t28 VSS.t27 nfet_03v3 ad=1.408p pd=7.28u as=0 ps=0 w=3.2u l=0.37u
X10 a_27028_n400.t1 XBUF.INP.t6 XBUF.INN.t2 VSS.t39 nfet_03v3 ad=1.76p pd=8.88u as=1.76p ps=8.88u w=4u l=0.28u
X11 VSS.t78 VCTRL.t7 a_27028_n400.t2 VSS.t77 nfet_03v3 ad=1.56p pd=6.52u as=2.64p ps=12.88u w=6u l=0.28u
X12 a_n3052_n500.t0 XBUF.INP.t9 XSTART.NODEP.t1 VSS.t30 nfet_03v3 ad=1.3p pd=5.52u as=2.2p ps=10.88u w=5u l=0.28u
X13 VSS.t94 KICKP.t0 XSTART.NODEP.t4 VSS.t93 nfet_03v3 ad=0.44p pd=2.88u as=0.44p ps=2.88u w=1u l=0.28u
X14 XSTART.NODEN.t3 XBUF.INN.t8 a_n3052_n500.t2 VSS.t11 nfet_03v3 ad=2.2p pd=10.88u as=1.3p ps=5.52u w=5u l=0.28u
X15 VSS.t54 VCTRL.t21 a_n3052_n500.t6 VSS.t53 nfet_03v3 ad=3.9p pd=15.52u as=3.9p ps=15.52u w=15u l=0.28u
X16 a_24948_n500.t1 X2.INN.t5 XBUF.INN.t0 VSS.t2 nfet_03v3 ad=1.3p pd=5.52u as=2.2p ps=10.88u w=5u l=0.28u
X17 VSS.t46 VCTRL.t11 a_24948_n500.t4 VSS.t45 nfet_03v3 ad=3.9p pd=15.52u as=6.6p ps=30.88u w=15u l=0.28u
X18 a_38948_n500.t5 VCTRL.t4 VSS.t84 VSS.t83 nfet_03v3 ad=3.9p pd=15.52u as=3.9p ps=15.52u w=15u l=0.28u
X19 a_10948_n500.t1 XSTART.NODEP.t6 X2.INP.t1 VSS.t7 nfet_03v3 ad=1.3p pd=5.52u as=2.2p ps=10.88u w=5u l=0.28u
X20 XBUF.INN.t1 X2.INN.t4 a_24948_n500.t2 VSS.t3 nfet_03v3 ad=2.2p pd=10.88u as=1.3p ps=5.52u w=5u l=0.28u
X21 a_24948_n500.t7 VCTRL.t8 VSS.t76 VSS.t75 nfet_03v3 ad=6.6p pd=30.88u as=3.9p ps=15.52u w=15u l=0.28u
X22 a_n972_n400.t3 XSTART.NODEN.t7 XSTART.NODEP.t3 VSS.t99 nfet_03v3 ad=1.76p pd=8.88u as=1.76p ps=8.88u w=4u l=0.28u
X23 X2.INP.t0 XSTART.NODEP.t5 a_10948_n500.t0 VSS.t6 nfet_03v3 ad=2.2p pd=10.88u as=1.3p ps=5.52u w=5u l=0.28u
X24 VSS.t97 KICKN.t0 XSTART.NODEN.t4 VSS.t96 nfet_03v3 ad=0.44p pd=2.88u as=0.44p ps=2.88u w=1u l=0.28u
X25 VSS.t68 VCTRL.t15 a_10948_n500.t4 VSS.t67 nfet_03v3 ad=3.9p pd=15.52u as=3.9p ps=15.52u w=15u l=0.28u
X26 a_27028_n400.t0 XBUF.INN.t6 XBUF.INP.t3 VSS.t9 nfet_03v3 ad=1.76p pd=8.88u as=1.76p ps=8.88u w=4u l=0.28u
X27 a_n972_n400.t0 XSTART.NODEP.t7 XSTART.NODEN.t1 VSS.t15 nfet_03v3 ad=1.76p pd=8.88u as=1.76p ps=8.88u w=4u l=0.28u
X28 VDD.t7 CLK_P.t3 VSS.t41 ppolyf_u r_width=2u r_length=4u
X29 VSS.t24 XSTART.NODEN.t8 VSS.t23 VSS.t5 nfet_03v3 ad=1.408p pd=7.28u as=0 ps=0 w=3.2u l=0.37u
X30 a_n3052_n500.t7 VCTRL.t20 VSS.t56 VSS.t55 nfet_03v3 ad=6.6p pd=30.88u as=3.9p ps=15.52u w=15u l=0.28u
X31 VSS.t50 VCTRL.t23 a_n3052_n500.t4 VSS.t49 nfet_03v3 ad=3.9p pd=15.52u as=6.6p ps=30.88u w=15u l=0.28u
X32 VSS.t14 XBUF.INN.t7 VSS.t13 VSS.t12 nfet_03v3 ad=1.408p pd=7.28u as=0 ps=0 w=3.2u l=0.37u
X33 VSS.t74 VCTRL.t9 a_24948_n500.t6 VSS.t73 nfet_03v3 ad=3.9p pd=15.52u as=3.9p ps=15.52u w=15u l=0.28u
X34 a_38948_n500.t3 XBUF.INP.t5 CLK_P.t2 VSS.t38 nfet_03v3 ad=1.3p pd=5.52u as=2.2p ps=10.88u w=5u l=0.28u
X35 a_41028_n400.t3 VCTRL.t0 VSS.t88 VSS.t87 nfet_03v3 ad=2.64p pd=12.88u as=1.56p ps=6.52u w=6u l=0.28u
X36 VSS.t37 X2.INP.t7 VSS.t36 VSS.t16 nfet_03v3 ad=1.408p pd=7.28u as=0 ps=0 w=3.2u l=0.37u
X37 CLK_P.t1 XBUF.INP.t4 a_38948_n500.t2 VSS.t34 nfet_03v3 ad=2.2p pd=10.88u as=1.3p ps=5.52u w=5u l=0.28u
X38 a_13028_n400.t1 X2.INP.t6 X2.INN.t0 VSS.t25 nfet_03v3 ad=1.76p pd=8.88u as=1.76p ps=8.88u w=4u l=0.28u
X39 a_10948_n500.t3 VCTRL.t16 VSS.t64 VSS.t63 nfet_03v3 ad=3.9p pd=15.52u as=3.9p ps=15.52u w=15u l=0.28u
X40 VDD.t5 X2.INN.t1 VSS.t20 ppolyf_u r_width=2u r_length=4u
X41 VSS.t19 XSTART.NODEP.t8 VSS.t18 VSS.t1 nfet_03v3 ad=1.408p pd=7.28u as=0 ps=0 w=3.2u l=0.37u
X42 a_41028_n400.t1 CLK_P.t4 CLK_N.t0 VSS.t44 nfet_03v3 ad=1.76p pd=8.88u as=1.76p ps=8.88u w=4u l=0.28u
X43 VDD.t0 XSTART.NODEP.t0 VSS.t1 ppolyf_u r_width=2u r_length=4u
X44 a_24948_n500.t5 VCTRL.t10 VSS.t72 VSS.t71 nfet_03v3 ad=3.9p pd=15.52u as=3.9p ps=15.52u w=15u l=0.28u
X45 VSS.t92 VCTRL.t1 a_41028_n400.t2 VSS.t91 nfet_03v3 ad=1.56p pd=6.52u as=2.64p ps=12.88u w=6u l=0.28u
X46 a_10948_n500.t6 XSTART.NODEN.t6 X2.INN.t2 VSS.t95 nfet_03v3 ad=1.3p pd=5.52u as=2.2p ps=10.88u w=5u l=0.28u
X47 a_13028_n400.t0 X2.INN.t6 X2.INP.t3 VSS.t10 nfet_03v3 ad=1.76p pd=8.88u as=1.76p ps=8.88u w=4u l=0.28u
X48 X2.INN.t3 XSTART.NODEN.t5 a_10948_n500.t7 VSS.t98 nfet_03v3 ad=2.2p pd=10.88u as=1.3p ps=5.52u w=5u l=0.28u
X49 VDD.t3 CLK_N.t2 VSS.t17 ppolyf_u r_width=2u r_length=4u
X50 VSS.t43 CLK_P.t5 VSS.t42 VSS.t41 nfet_03v3 ad=1.408p pd=7.28u as=0 ps=0 w=3.2u l=0.37u
X51 VDD.t4 XBUF.INP.t2 VSS.t27 ppolyf_u r_width=2u r_length=4u
X52 VSS.t82 VCTRL.t5 a_38948_n500.t4 VSS.t81 nfet_03v3 ad=3.9p pd=15.52u as=6.6p ps=30.88u w=15u l=0.28u
X53 a_38948_n500.t0 XBUF.INN.t5 CLK_N.t1 VSS.t8 nfet_03v3 ad=1.3p pd=5.52u as=2.2p ps=10.88u w=5u l=0.28u
X54 a_38948_n500.t7 VCTRL.t2 VSS.t90 VSS.t89 nfet_03v3 ad=6.6p pd=30.88u as=3.9p ps=15.52u w=15u l=0.28u
X55 a_13028_n400.t3 VCTRL.t12 VSS.t48 VSS.t47 nfet_03v3 ad=2.64p pd=12.88u as=1.56p ps=6.52u w=6u l=0.28u
X56 a_41028_n400.t0 CLK_N.t4 CLK_P.t0 VSS.t33 nfet_03v3 ad=1.76p pd=8.88u as=1.76p ps=8.88u w=4u l=0.28u
X57 a_24948_n500.t0 X2.INP.t5 XBUF.INP.t0 VSS.t0 nfet_03v3 ad=1.3p pd=5.52u as=2.2p ps=10.88u w=5u l=0.28u
X58 CLK_N.t3 XBUF.INN.t4 a_38948_n500.t1 VSS.t26 nfet_03v3 ad=2.2p pd=10.88u as=1.3p ps=5.52u w=5u l=0.28u
X59 XBUF.INP.t1 X2.INP.t4 a_24948_n500.t3 VSS.t4 nfet_03v3 ad=2.2p pd=10.88u as=1.3p ps=5.52u w=5u l=0.28u
X60 a_27028_n400.t3 VCTRL.t6 VSS.t80 VSS.t79 nfet_03v3 ad=2.64p pd=12.88u as=1.56p ps=6.52u w=6u l=0.28u
X61 a_n972_n400.t2 VCTRL.t18 VSS.t62 VSS.t61 nfet_03v3 ad=2.64p pd=12.88u as=1.56p ps=6.52u w=6u l=0.28u
X62 VSS.t22 X2.INN.t7 VSS.t21 VSS.t20 nfet_03v3 ad=1.408p pd=7.28u as=0 ps=0 w=3.2u l=0.37u
X63 a_n3052_n500.t5 VCTRL.t22 VSS.t52 VSS.t51 nfet_03v3 ad=3.9p pd=15.52u as=3.9p ps=15.52u w=15u l=0.28u
X64 VSS.t86 VCTRL.t3 a_38948_n500.t6 VSS.t85 nfet_03v3 ad=3.9p pd=15.52u as=3.9p ps=15.52u w=15u l=0.28u
X65 VSS.t66 VCTRL.t13 a_13028_n400.t2 VSS.t65 nfet_03v3 ad=1.56p pd=6.52u as=2.64p ps=12.88u w=6u l=0.28u
R0 CLK_N.n4 CLK_N.t4 96.4943
R1 CLK_N.n0 CLK_N.t5 64.1282
R2 CLK_N.n4 CLK_N.t2 31.4224
R3 CLK_N.n4 CLK_N.t0 11.0041
R4 CLK_N.n1 CLK_N.t3 5.69917
R5 CLK_N.n2 CLK_N.t1 5.69917
R6 CLK_N.n1 CLK_N.n0 4.5805
R7 CLK_N.n3 CLK_N.n2 4.5005
R8 CLK_N.n2 CLK_N.n1 0.189974
R9 CLK_N CLK_N.n3 0.1705
R10 CLK_N CLK_N.n4 0.1505
R11 CLK_N.n3 CLK_N.n0 0.0805
R12 CLK_P.n1 CLK_P.t4 94.691
R13 CLK_P.n0 CLK_P.t5 64.1282
R14 CLK_P.n1 CLK_P.t3 22.0076
R15 CLK_P.n2 CLK_P.t0 10.9241
R16 CLK_P.n4 CLK_P.t1 5.69917
R17 CLK_P.n5 CLK_P.t2 5.69917
R18 CLK_P.n2 CLK_P.n1 4.80115
R19 CLK_P.n6 CLK_P.n5 4.5005
R20 CLK_P.n4 CLK_P.n3 4.5005
R21 CLK_P.n3 CLK_P.n2 0.3205
R22 CLK_P.n5 CLK_P.n4 0.189974
R23 CLK_P.n6 CLK_P.n0 0.0805
R24 CLK_P.n3 CLK_P.n0 0.0805
R25 CLK_P CLK_P.n6 0.0205
R26 VCTRL.n23 VCTRL.t23 204.881
R27 VCTRL.n20 VCTRL.t20 204.881
R28 VCTRL.n17 VCTRL.t17 204.881
R29 VCTRL.n14 VCTRL.t14 204.881
R30 VCTRL.n11 VCTRL.t11 204.881
R31 VCTRL.n8 VCTRL.t8 204.881
R32 VCTRL.n4 VCTRL.t5 204.881
R33 VCTRL.n1 VCTRL.t2 204.881
R34 VCTRL.n21 VCTRL.t21 200.424
R35 VCTRL.n22 VCTRL.t22 200.424
R36 VCTRL.n15 VCTRL.t15 200.424
R37 VCTRL.n16 VCTRL.t16 200.424
R38 VCTRL.n9 VCTRL.t9 200.424
R39 VCTRL.n10 VCTRL.t10 200.424
R40 VCTRL.n2 VCTRL.t3 200.424
R41 VCTRL.n3 VCTRL.t4 200.424
R42 VCTRL.n19 VCTRL.t18 87.5461
R43 VCTRL.n19 VCTRL.t19 87.5461
R44 VCTRL.n13 VCTRL.t12 87.5461
R45 VCTRL.n13 VCTRL.t13 87.5461
R46 VCTRL.n7 VCTRL.t6 87.5461
R47 VCTRL.n7 VCTRL.t7 87.5461
R48 VCTRL.n0 VCTRL.t0 87.5461
R49 VCTRL.n0 VCTRL.t1 87.5461
R50 VCTRL.n25 VCTRL.n19 20.7532
R51 VCTRL.n26 VCTRL.n13 20.7532
R52 VCTRL.n27 VCTRL.n7 20.7532
R53 VCTRL.n6 VCTRL.n0 20.7532
R54 VCTRL.n25 VCTRL.n24 15.6013
R55 VCTRL.n26 VCTRL.n18 15.6013
R56 VCTRL.n27 VCTRL.n12 15.6013
R57 VCTRL.n6 VCTRL.n5 15.6013
R58 VCTRL.n22 VCTRL.n21 11.6805
R59 VCTRL.n16 VCTRL.n15 11.6805
R60 VCTRL.n10 VCTRL.n9 11.6805
R61 VCTRL.n3 VCTRL.n2 11.6805
R62 VCTRL.n26 VCTRL.n25 8.28997
R63 VCTRL.n27 VCTRL.n26 8.28997
R64 VCTRL VCTRL.n27 7.57945
R65 VCTRL.n24 VCTRL.n20 7.10487
R66 VCTRL.n24 VCTRL.n23 7.10487
R67 VCTRL.n18 VCTRL.n14 7.10487
R68 VCTRL.n18 VCTRL.n17 7.10487
R69 VCTRL.n12 VCTRL.n8 7.10487
R70 VCTRL.n12 VCTRL.n11 7.10487
R71 VCTRL.n5 VCTRL.n1 7.10487
R72 VCTRL.n5 VCTRL.n4 7.10487
R73 VCTRL.n21 VCTRL.n20 4.42851
R74 VCTRL.n23 VCTRL.n22 4.42851
R75 VCTRL.n15 VCTRL.n14 4.42851
R76 VCTRL.n17 VCTRL.n16 4.42851
R77 VCTRL.n9 VCTRL.n8 4.42851
R78 VCTRL.n11 VCTRL.n10 4.42851
R79 VCTRL.n2 VCTRL.n1 4.42851
R80 VCTRL.n4 VCTRL.n3 4.42851
R81 VCTRL VCTRL.n6 0.711026
R82 VDD.n0 VDD.t3 21.7267
R83 VDD.n3 VDD.t0 21.7267
R84 VDD.n0 VDD.t7 21.205
R85 VDD.n1 VDD.t6 21.205
R86 VDD.n2 VDD.t4 21.205
R87 VDD.n5 VDD.t5 21.205
R88 VDD.n4 VDD.t2 21.205
R89 VDD.n3 VDD.t1 21.205
R90 VDD.n4 VDD.n3 0.696152
R91 VDD.n1 VDD.n0 0.696152
R92 VDD.n5 VDD.n4 0.522239
R93 VDD.n2 VDD.n1 0.522239
R94 VDD VDD.n2 0.4005
R95 VDD VDD.n5 0.296152
R96 KICKN KICKN.t0 77.7323
R97 KICKP KICKP.t0 77.7323
R98 VSS.n259 VSS.n230 558.396
R99 VSS.n326 VSS.n297 558.396
R100 VSS.n365 VSS.n364 558.396
R101 VSS.n184 VSS.n143 199.428
R102 VSS.n209 VSS.n87 199.428
R103 VSS.n261 VSS.n260 199.428
R104 VSS.n275 VSS.n49 199.428
R105 VSS.n328 VSS.n327 199.428
R106 VSS.n342 VSS.n13 199.428
R107 VSS.n461 VSS.n9 199.428
R108 VSS.n409 VSS.n383 199.428
R109 VSS.n268 VSS.t10 166.19
R110 VSS.t25 VSS.n268 166.19
R111 VSS.n335 VSS.t9 166.19
R112 VSS.t39 VSS.n335 166.19
R113 VSS.n422 VSS.t33 166.19
R114 VSS.n422 VSS.t44 166.19
R115 VSS.t93 VSS.n101 132.952
R116 VSS.t96 VSS.n101 132.952
R117 VSS.t47 VSS.n64 119.656
R118 VSS.t79 VSS.n27 119.656
R119 VSS.n416 VSS.t87 119.656
R120 VSS.n78 VSS.t59 93.0666
R121 VSS.n41 VSS.t45 93.0666
R122 VSS.n430 VSS.t81 93.0666
R123 VSS.n184 VSS.n144 86.419
R124 VSS.n230 VSS.n87 86.419
R125 VSS.n260 VSS.n259 86.419
R126 VSS.n297 VSS.n49 86.419
R127 VSS.n327 VSS.n326 86.419
R128 VSS.n364 VSS.n13 86.419
R129 VSS.n461 VSS.n365 86.419
R130 VSS.n409 VSS.n381 86.419
R131 VSS.t61 VSS.n122 73.1238
R132 VSS.n185 VSS.n141 59.5005
R133 VSS.n228 VSS.n91 59.5005
R134 VSS.n408 VSS.n384 59.5005
R135 VSS.n460 VSS.n367 59.5005
R136 VSS.n362 VSS.n16 59.5005
R137 VSS.n325 VSS.n33 59.5005
R138 VSS.n295 VSS.n53 59.5005
R139 VSS.n258 VSS.n70 59.5005
R140 VSS.n203 VSS.t57 53.1811
R141 VSS.n269 VSS.t65 53.1811
R142 VSS.n336 VSS.t77 53.1811
R143 VSS.t91 VSS.n415 53.1811
R144 VSS.n183 VSS.n145 52.5005
R145 VSS.n145 VSS.n135 52.5005
R146 VSS.n178 VSS.n135 52.5005
R147 VSS.n178 VSS.n175 52.5005
R148 VSS.n175 VSS.n100 52.5005
R149 VSS.n100 VSS.n95 52.5005
R150 VSS.n210 VSS.n95 52.5005
R151 VSS.n211 VSS.n210 52.5005
R152 VSS.n164 VSS.n163 52.5005
R153 VSS.n161 VSS.n148 52.5005
R154 VSS.n157 VSS.n155 52.5005
R155 VSS.n151 VSS.n141 52.5005
R156 VSS.n185 VSS.n138 52.5005
R157 VSS.n189 VSS.n138 52.5005
R158 VSS.n189 VSS.n137 52.5005
R159 VSS.n137 VSS.n99 52.5005
R160 VSS.n204 VSS.n99 52.5005
R161 VSS.n204 VSS.n97 52.5005
R162 VSS.n208 VSS.n97 52.5005
R163 VSS.n208 VSS.n91 52.5005
R164 VSS.n214 VSS.n88 52.5005
R165 VSS.n216 VSS.n85 52.5005
R166 VSS.n219 VSS.n85 52.5005
R167 VSS.n221 VSS.n89 52.5005
R168 VSS.n90 VSS.n89 52.5005
R169 VSS.n460 VSS.n366 52.5005
R170 VSS.n431 VSS.n366 52.5005
R171 VSS.n431 VSS.n369 52.5005
R172 VSS.n421 VSS.n369 52.5005
R173 VSS.n421 VSS.n374 52.5005
R174 VSS.n417 VSS.n374 52.5005
R175 VSS.n417 VSS.n376 52.5005
R176 VSS.n408 VSS.n376 52.5005
R177 VSS.n395 VSS.n391 52.5005
R178 VSS.n398 VSS.n397 52.5005
R179 VSS.n402 VSS.n401 52.5005
R180 VSS.n404 VSS.n402 52.5005
R181 VSS.n462 VSS.n7 52.5005
R182 VSS.n427 VSS.n7 52.5005
R183 VSS.n427 VSS.n370 52.5005
R184 VSS.n423 VSS.n370 52.5005
R185 VSS.n423 VSS.n372 52.5005
R186 VSS.n414 VSS.n372 52.5005
R187 VSS.n414 VSS.n378 52.5005
R188 VSS.n410 VSS.n378 52.5005
R189 VSS.n447 VSS.n446 52.5005
R190 VSS.n451 VSS.n438 52.5005
R191 VSS.n454 VSS.n453 52.5005
R192 VSS.n456 VSS.n367 52.5005
R193 VSS.n329 VSS.n33 52.5005
R194 VSS.n329 VSS.n31 52.5005
R195 VSS.n333 VSS.n31 52.5005
R196 VSS.n333 VSS.n25 52.5005
R197 VSS.n337 VSS.n25 52.5005
R198 VSS.n337 VSS.n23 52.5005
R199 VSS.n341 VSS.n23 52.5005
R200 VSS.n341 VSS.n16 52.5005
R201 VSS.n347 VSS.n14 52.5005
R202 VSS.n350 VSS.n14 52.5005
R203 VSS.n354 VSS.n353 52.5005
R204 VSS.n358 VSS.n15 52.5005
R205 VSS.n46 VSS.n35 52.5005
R206 VSS.n42 VSS.n35 52.5005
R207 VSS.n42 VSS.n30 52.5005
R208 VSS.n30 VSS.n29 52.5005
R209 VSS.n29 VSS.n28 52.5005
R210 VSS.n28 VSS.n20 52.5005
R211 VSS.n343 VSS.n20 52.5005
R212 VSS.n344 VSS.n343 52.5005
R213 VSS.n313 VSS.n312 52.5005
R214 VSS.n317 VSS.n316 52.5005
R215 VSS.n321 VSS.n320 52.5005
R216 VSS.n325 VSS.n302 52.5005
R217 VSS.n262 VSS.n70 52.5005
R218 VSS.n262 VSS.n68 52.5005
R219 VSS.n266 VSS.n68 52.5005
R220 VSS.n266 VSS.n62 52.5005
R221 VSS.n270 VSS.n62 52.5005
R222 VSS.n270 VSS.n60 52.5005
R223 VSS.n274 VSS.n60 52.5005
R224 VSS.n274 VSS.n53 52.5005
R225 VSS.n282 VSS.n281 52.5005
R226 VSS.n286 VSS.n285 52.5005
R227 VSS.n288 VSS.n51 52.5005
R228 VSS.n52 VSS.n51 52.5005
R229 VSS.n83 VSS.n72 52.5005
R230 VSS.n79 VSS.n72 52.5005
R231 VSS.n79 VSS.n67 52.5005
R232 VSS.n67 VSS.n66 52.5005
R233 VSS.n66 VSS.n65 52.5005
R234 VSS.n65 VSS.n57 52.5005
R235 VSS.n276 VSS.n57 52.5005
R236 VSS.n277 VSS.n276 52.5005
R237 VSS.n246 VSS.n245 52.5005
R238 VSS.n250 VSS.n249 52.5005
R239 VSS.n254 VSS.n253 52.5005
R240 VSS.n258 VSS.n235 52.5005
R241 VSS.n191 VSS.n190 46.5335
R242 VSS.n191 VSS.t49 46.5335
R243 VSS.n122 VSS.n113 46.5335
R244 VSS.n142 VSS.t30 45.8688
R245 VSS.t40 VSS.n136 45.8688
R246 VSS.n112 VSS.t35 45.8688
R247 VSS.t11 VSS.n96 45.8688
R248 VSS.t7 VSS.n71 45.8688
R249 VSS.n77 VSS.t6 45.8688
R250 VSS.n63 VSS.t95 45.8688
R251 VSS.t98 VSS.n59 45.8688
R252 VSS.t0 VSS.n34 45.8688
R253 VSS.n40 VSS.t4 45.8688
R254 VSS.n26 VSS.t2 45.8688
R255 VSS.t3 VSS.n22 45.8688
R256 VSS.n428 VSS.t38 45.8688
R257 VSS.n429 VSS.t34 45.8688
R258 VSS.t8 VSS.n377 45.8688
R259 VSS.n382 VSS.t26 45.8688
R260 VSS.n183 VSS.n171 42.0005
R261 VSS.n211 VSS.n88 42.0005
R262 VSS.n410 VSS.n380 42.0005
R263 VSS.n462 VSS.n8 42.0005
R264 VSS.n345 VSS.n344 42.0005
R265 VSS.n305 VSS.n46 42.0005
R266 VSS.n278 VSS.n277 42.0005
R267 VSS.n238 VSS.n83 42.0005
R268 VSS.n124 VSS.n111 42.0005
R269 VSS.n193 VSS.n109 42.0005
R270 VSS.n130 VSS.n107 42.0005
R271 VSS.n120 VSS.n103 42.0005
R272 VSS.n143 VSS.n142 40.5507
R273 VSS.n190 VSS.n136 40.5507
R274 VSS.n113 VSS.n112 40.5507
R275 VSS.n209 VSS.n96 40.5507
R276 VSS.n261 VSS.n71 40.5507
R277 VSS.n78 VSS.n77 40.5507
R278 VSS.n64 VSS.n63 40.5507
R279 VSS.n275 VSS.n59 40.5507
R280 VSS.n328 VSS.n34 40.5507
R281 VSS.n41 VSS.n40 40.5507
R282 VSS.n27 VSS.n26 40.5507
R283 VSS.n342 VSS.n22 40.5507
R284 VSS.n428 VSS.n9 40.5507
R285 VSS.n430 VSS.n429 40.5507
R286 VSS.n416 VSS.n377 40.5507
R287 VSS.n383 VSS.n382 40.5507
R288 VSS.n197 VSS.n109 35.0005
R289 VSS.n197 VSS.n108 35.0005
R290 VSS.n108 VSS.n102 35.0005
R291 VSS.n124 VSS.n102 35.0005
R292 VSS.n198 VSS.n107 35.0005
R293 VSS.n198 VSS.n104 35.0005
R294 VSS.n202 VSS.n104 35.0005
R295 VSS.n202 VSS.n103 35.0005
R296 VSS.n177 VSS.t99 33.2384
R297 VSS.t93 VSS.t99 33.2384
R298 VSS.t15 VSS.t96 33.2384
R299 VSS.n203 VSS.t15 33.2384
R300 VSS.t10 VSS.n267 33.2384
R301 VSS.n269 VSS.t25 33.2384
R302 VSS.t9 VSS.n334 33.2384
R303 VSS.n336 VSS.t39 33.2384
R304 VSS.t33 VSS.n373 33.2384
R305 VSS.n415 VSS.t44 33.2384
R306 VSS.t51 VSS.t49 26.5908
R307 VSS.t55 VSS.t53 26.5908
R308 VSS.n177 VSS.t55 26.5908
R309 VSS.t59 VSS.t63 26.5908
R310 VSS.t63 VSS.t67 26.5908
R311 VSS.t67 VSS.t69 26.5908
R312 VSS.n267 VSS.t69 26.5908
R313 VSS.t65 VSS.t47 26.5908
R314 VSS.t45 VSS.t71 26.5908
R315 VSS.t71 VSS.t73 26.5908
R316 VSS.t73 VSS.t75 26.5908
R317 VSS.n334 VSS.t75 26.5908
R318 VSS.t77 VSS.t79 26.5908
R319 VSS.t83 VSS.t81 26.5908
R320 VSS.t85 VSS.t83 26.5908
R321 VSS.t89 VSS.t85 26.5908
R322 VSS.n373 VSS.t89 26.5908
R323 VSS.t87 VSS.t91 26.5908
R324 VSS.n116 VSS.n115 26.2505
R325 VSS.n133 VSS.n129 26.2505
R326 VSS.n387 VSS.t31 20.7288
R327 VSS.n357 VSS.t13 20.7288
R328 VSS.n291 VSS.t21 20.7288
R329 VSS.n224 VSS.t23 20.7288
R330 VSS.n436 VSS.t42 20.6733
R331 VSS.n304 VSS.t28 20.6733
R332 VSS.n237 VSS.t36 20.6733
R333 VSS.n149 VSS.t18 20.6733
R334 VSS.n393 VSS.n392 20.6665
R335 VSS.n348 VSS.n18 20.6665
R336 VSS.n280 VSS.n55 20.6665
R337 VSS.n215 VSS.n93 20.6665
R338 VSS.n388 VSS.t32 20.6363
R339 VSS.n356 VSS.t14 20.6363
R340 VSS.n290 VSS.t22 20.6363
R341 VSS.n223 VSS.t24 20.6363
R342 VSS.n435 VSS.t43 20.6038
R343 VSS.n303 VSS.t29 20.6038
R344 VSS.n236 VSS.t37 20.6038
R345 VSS.n153 VSS.t19 20.6038
R346 VSS.n465 VSS.n464 17.1834
R347 VSS.n1 VSS.t97 14.4535
R348 VSS.n1 VSS.t94 14.3735
R349 VSS.t30 VSS.t1 13.2957
R350 VSS.t1 VSS.t40 13.2957
R351 VSS.n176 VSS.t51 13.2957
R352 VSS.t53 VSS.n176 13.2957
R353 VSS.n123 VSS.t57 13.2957
R354 VSS.n123 VSS.t61 13.2957
R355 VSS.t35 VSS.t5 13.2957
R356 VSS.t5 VSS.t11 13.2957
R357 VSS.t16 VSS.t7 13.2957
R358 VSS.t6 VSS.t16 13.2957
R359 VSS.t95 VSS.t20 13.2957
R360 VSS.t20 VSS.t98 13.2957
R361 VSS.t27 VSS.t0 13.2957
R362 VSS.t4 VSS.t27 13.2957
R363 VSS.t2 VSS.t12 13.2957
R364 VSS.t12 VSS.t3 13.2957
R365 VSS.t38 VSS.t41 13.2957
R366 VSS.t41 VSS.t34 13.2957
R367 VSS.t17 VSS.t8 13.2957
R368 VSS.t26 VSS.t17 13.2957
R369 VSS.n442 VSS.n441 13.0239
R370 VSS.n310 VSS.n309 13.0239
R371 VSS.n243 VSS.n242 13.0239
R372 VSS.n169 VSS.n168 13.0239
R373 VSS.n468 VSS.n0 9.30839
R374 VSS.n465 VSS.n4 9.30839
R375 VSS.n466 VSS.n3 9.30839
R376 VSS.n127 VSS.n2 9.0005
R377 VSS.n466 VSS.n465 7.8755
R378 VSS.n467 VSS.n2 7.41366
R379 VSS.n441 VSS.n440 5.83696
R380 VSS.n309 VSS.n308 5.83696
R381 VSS.n242 VSS.n241 5.83696
R382 VSS.n168 VSS.n167 5.83696
R383 VSS.n441 VSS.n439 5.83371
R384 VSS.n309 VSS.n307 5.83371
R385 VSS.n242 VSS.n240 5.83371
R386 VSS.n168 VSS.n166 5.83371
R387 VSS.n144 VSS.n141 5.2005
R388 VSS.n141 VSS.n140 5.2005
R389 VSS.n152 VSS.n151 5.2005
R390 VSS.n155 VSS.n154 5.2005
R391 VSS.n158 VSS.n157 5.2005
R392 VSS.n159 VSS.n148 5.2005
R393 VSS.n161 VSS.n160 5.2005
R394 VSS.n163 VSS.n147 5.2005
R395 VSS.n165 VSS.n164 5.2005
R396 VSS.n171 VSS.n170 5.2005
R397 VSS.n91 VSS.n87 5.2005
R398 VSS.n92 VSS.n91 5.2005
R399 VSS.n209 VSS.n208 5.2005
R400 VSS.n208 VSS.n207 5.2005
R401 VSS.n113 VSS.n97 5.2005
R402 VSS.n206 VSS.n97 5.2005
R403 VSS.n204 VSS.n203 5.2005
R404 VSS.n205 VSS.n204 5.2005
R405 VSS.n101 VSS.n99 5.2005
R406 VSS.n99 VSS.n98 5.2005
R407 VSS.n177 VSS.n137 5.2005
R408 VSS.n139 VSS.n137 5.2005
R409 VSS.n190 VSS.n189 5.2005
R410 VSS.n189 VSS.n188 5.2005
R411 VSS.n143 VSS.n138 5.2005
R412 VSS.n187 VSS.n138 5.2005
R413 VSS.n185 VSS.n184 5.2005
R414 VSS.n186 VSS.n185 5.2005
R415 VSS.n230 VSS.n88 5.2005
R416 VSS.n213 VSS.n88 5.2005
R417 VSS.n215 VSS.n214 5.2005
R418 VSS.n217 VSS.n216 5.2005
R419 VSS.n230 VSS.n85 5.2005
R420 VSS.n218 VSS.n85 5.2005
R421 VSS.n220 VSS.n219 5.2005
R422 VSS.n222 VSS.n221 5.2005
R423 VSS.n230 VSS.n89 5.2005
R424 VSS.n225 VSS.n89 5.2005
R425 VSS.n226 VSS.n90 5.2005
R426 VSS.n228 VSS.n227 5.2005
R427 VSS.n211 VSS.n87 5.2005
R428 VSS.n212 VSS.n211 5.2005
R429 VSS.n210 VSS.n209 5.2005
R430 VSS.n210 VSS.n94 5.2005
R431 VSS.n113 VSS.n95 5.2005
R432 VSS.n172 VSS.n95 5.2005
R433 VSS.n203 VSS.n100 5.2005
R434 VSS.n173 VSS.n100 5.2005
R435 VSS.n175 VSS.n101 5.2005
R436 VSS.n175 VSS.n174 5.2005
R437 VSS.n178 VSS.n177 5.2005
R438 VSS.n179 VSS.n178 5.2005
R439 VSS.n190 VSS.n135 5.2005
R440 VSS.n180 VSS.n135 5.2005
R441 VSS.n145 VSS.n143 5.2005
R442 VSS.n181 VSS.n145 5.2005
R443 VSS.n184 VSS.n183 5.2005
R444 VSS.n183 VSS.n182 5.2005
R445 VSS.n176 VSS.n107 5.2005
R446 VSS.n107 VSS.n106 5.2005
R447 VSS.n198 VSS.t93 5.2005
R448 VSS.n199 VSS.n198 5.2005
R449 VSS.n104 VSS.n101 5.2005
R450 VSS.n200 VSS.n104 5.2005
R451 VSS.t96 VSS.n202 5.2005
R452 VSS.n202 VSS.n201 5.2005
R453 VSS.n123 VSS.n103 5.2005
R454 VSS.n105 VSS.n103 5.2005
R455 VSS.n124 VSS.n123 5.2005
R456 VSS.n125 VSS.n124 5.2005
R457 VSS.t96 VSS.n102 5.2005
R458 VSS.n126 VSS.n102 5.2005
R459 VSS.n108 VSS.n101 5.2005
R460 VSS.n127 VSS.n108 5.2005
R461 VSS.t93 VSS.n197 5.2005
R462 VSS.n197 VSS.n196 5.2005
R463 VSS.n176 VSS.n109 5.2005
R464 VSS.n195 VSS.n109 5.2005
R465 VSS.n131 VSS.n130 5.2005
R466 VSS.n133 VSS.n132 5.2005
R467 VSS.n129 VSS.n128 5.2005
R468 VSS.n194 VSS.n193 5.2005
R469 VSS.n111 VSS.n110 5.2005
R470 VSS.n117 VSS.n116 5.2005
R471 VSS.n118 VSS.n115 5.2005
R472 VSS.n120 VSS.n119 5.2005
R473 VSS.n277 VSS.n49 5.2005
R474 VSS.n277 VSS.n56 5.2005
R475 VSS.n276 VSS.n275 5.2005
R476 VSS.n276 VSS.n58 5.2005
R477 VSS.n64 VSS.n57 5.2005
R478 VSS.n73 VSS.n57 5.2005
R479 VSS.n269 VSS.n65 5.2005
R480 VSS.n74 VSS.n65 5.2005
R481 VSS.n268 VSS.n66 5.2005
R482 VSS.n75 VSS.n66 5.2005
R483 VSS.n267 VSS.n67 5.2005
R484 VSS.n76 VSS.n67 5.2005
R485 VSS.n79 VSS.n78 5.2005
R486 VSS.n80 VSS.n79 5.2005
R487 VSS.n261 VSS.n72 5.2005
R488 VSS.n81 VSS.n72 5.2005
R489 VSS.n260 VSS.n83 5.2005
R490 VSS.n83 VSS.n82 5.2005
R491 VSS.n259 VSS.n258 5.2005
R492 VSS.n258 VSS.n257 5.2005
R493 VSS.n256 VSS.n235 5.2005
R494 VSS.n255 VSS.n254 5.2005
R495 VSS.n253 VSS.n252 5.2005
R496 VSS.n251 VSS.n250 5.2005
R497 VSS.n249 VSS.n248 5.2005
R498 VSS.n247 VSS.n246 5.2005
R499 VSS.n245 VSS.n244 5.2005
R500 VSS.n239 VSS.n238 5.2005
R501 VSS.n279 VSS.n278 5.2005
R502 VSS.n281 VSS.n280 5.2005
R503 VSS.n283 VSS.n282 5.2005
R504 VSS.n285 VSS.n284 5.2005
R505 VSS.n287 VSS.n286 5.2005
R506 VSS.n289 VSS.n288 5.2005
R507 VSS.n297 VSS.n51 5.2005
R508 VSS.n292 VSS.n51 5.2005
R509 VSS.n293 VSS.n52 5.2005
R510 VSS.n295 VSS.n294 5.2005
R511 VSS.n53 VSS.n49 5.2005
R512 VSS.n54 VSS.n53 5.2005
R513 VSS.n275 VSS.n274 5.2005
R514 VSS.n274 VSS.n273 5.2005
R515 VSS.n64 VSS.n60 5.2005
R516 VSS.n272 VSS.n60 5.2005
R517 VSS.n270 VSS.n269 5.2005
R518 VSS.n271 VSS.n270 5.2005
R519 VSS.n268 VSS.n62 5.2005
R520 VSS.n62 VSS.n61 5.2005
R521 VSS.n267 VSS.n266 5.2005
R522 VSS.n266 VSS.n265 5.2005
R523 VSS.n78 VSS.n68 5.2005
R524 VSS.n264 VSS.n68 5.2005
R525 VSS.n262 VSS.n261 5.2005
R526 VSS.n263 VSS.n262 5.2005
R527 VSS.n260 VSS.n70 5.2005
R528 VSS.n70 VSS.n69 5.2005
R529 VSS.n344 VSS.n13 5.2005
R530 VSS.n344 VSS.n19 5.2005
R531 VSS.n343 VSS.n342 5.2005
R532 VSS.n343 VSS.n21 5.2005
R533 VSS.n27 VSS.n20 5.2005
R534 VSS.n36 VSS.n20 5.2005
R535 VSS.n336 VSS.n28 5.2005
R536 VSS.n37 VSS.n28 5.2005
R537 VSS.n335 VSS.n29 5.2005
R538 VSS.n38 VSS.n29 5.2005
R539 VSS.n334 VSS.n30 5.2005
R540 VSS.n39 VSS.n30 5.2005
R541 VSS.n42 VSS.n41 5.2005
R542 VSS.n43 VSS.n42 5.2005
R543 VSS.n328 VSS.n35 5.2005
R544 VSS.n44 VSS.n35 5.2005
R545 VSS.n327 VSS.n46 5.2005
R546 VSS.n46 VSS.n45 5.2005
R547 VSS.n326 VSS.n325 5.2005
R548 VSS.n325 VSS.n324 5.2005
R549 VSS.n323 VSS.n302 5.2005
R550 VSS.n322 VSS.n321 5.2005
R551 VSS.n320 VSS.n319 5.2005
R552 VSS.n318 VSS.n317 5.2005
R553 VSS.n316 VSS.n315 5.2005
R554 VSS.n314 VSS.n313 5.2005
R555 VSS.n312 VSS.n311 5.2005
R556 VSS.n306 VSS.n305 5.2005
R557 VSS.n346 VSS.n345 5.2005
R558 VSS.n348 VSS.n347 5.2005
R559 VSS.n364 VSS.n14 5.2005
R560 VSS.n349 VSS.n14 5.2005
R561 VSS.n351 VSS.n350 5.2005
R562 VSS.n353 VSS.n352 5.2005
R563 VSS.n355 VSS.n354 5.2005
R564 VSS.n359 VSS.n358 5.2005
R565 VSS.n360 VSS.n15 5.2005
R566 VSS.n362 VSS.n361 5.2005
R567 VSS.n16 VSS.n13 5.2005
R568 VSS.n17 VSS.n16 5.2005
R569 VSS.n342 VSS.n341 5.2005
R570 VSS.n341 VSS.n340 5.2005
R571 VSS.n27 VSS.n23 5.2005
R572 VSS.n339 VSS.n23 5.2005
R573 VSS.n337 VSS.n336 5.2005
R574 VSS.n338 VSS.n337 5.2005
R575 VSS.n335 VSS.n25 5.2005
R576 VSS.n25 VSS.n24 5.2005
R577 VSS.n334 VSS.n333 5.2005
R578 VSS.n333 VSS.n332 5.2005
R579 VSS.n41 VSS.n31 5.2005
R580 VSS.n331 VSS.n31 5.2005
R581 VSS.n329 VSS.n328 5.2005
R582 VSS.n330 VSS.n329 5.2005
R583 VSS.n327 VSS.n33 5.2005
R584 VSS.n33 VSS.n32 5.2005
R585 VSS.n410 VSS.n409 5.2005
R586 VSS.n411 VSS.n410 5.2005
R587 VSS.n383 VSS.n378 5.2005
R588 VSS.n412 VSS.n378 5.2005
R589 VSS.n416 VSS.n414 5.2005
R590 VSS.n414 VSS.n413 5.2005
R591 VSS.n415 VSS.n372 5.2005
R592 VSS.n372 VSS.n371 5.2005
R593 VSS.n423 VSS.n422 5.2005
R594 VSS.n424 VSS.n423 5.2005
R595 VSS.n373 VSS.n370 5.2005
R596 VSS.n425 VSS.n370 5.2005
R597 VSS.n430 VSS.n427 5.2005
R598 VSS.n427 VSS.n426 5.2005
R599 VSS.n9 VSS.n7 5.2005
R600 VSS.n7 VSS.n6 5.2005
R601 VSS.n462 VSS.n461 5.2005
R602 VSS.n463 VSS.n462 5.2005
R603 VSS.n367 VSS.n365 5.2005
R604 VSS.n458 VSS.n367 5.2005
R605 VSS.n457 VSS.n456 5.2005
R606 VSS.n454 VSS.n434 5.2005
R607 VSS.n453 VSS.n437 5.2005
R608 VSS.n451 VSS.n450 5.2005
R609 VSS.n449 VSS.n438 5.2005
R610 VSS.n448 VSS.n447 5.2005
R611 VSS.n446 VSS.n443 5.2005
R612 VSS.n8 VSS.n5 5.2005
R613 VSS.n380 VSS.n379 5.2005
R614 VSS.n393 VSS.n391 5.2005
R615 VSS.n395 VSS.n394 5.2005
R616 VSS.n397 VSS.n389 5.2005
R617 VSS.n399 VSS.n398 5.2005
R618 VSS.n401 VSS.n400 5.2005
R619 VSS.n402 VSS.n381 5.2005
R620 VSS.n402 VSS.n385 5.2005
R621 VSS.n405 VSS.n404 5.2005
R622 VSS.n406 VSS.n384 5.2005
R623 VSS.n409 VSS.n408 5.2005
R624 VSS.n408 VSS.n407 5.2005
R625 VSS.n383 VSS.n376 5.2005
R626 VSS.n376 VSS.n375 5.2005
R627 VSS.n417 VSS.n416 5.2005
R628 VSS.n418 VSS.n417 5.2005
R629 VSS.n415 VSS.n374 5.2005
R630 VSS.n419 VSS.n374 5.2005
R631 VSS.n422 VSS.n421 5.2005
R632 VSS.n421 VSS.n420 5.2005
R633 VSS.n373 VSS.n369 5.2005
R634 VSS.n369 VSS.n368 5.2005
R635 VSS.n431 VSS.n430 5.2005
R636 VSS.n432 VSS.n431 5.2005
R637 VSS.n366 VSS.n9 5.2005
R638 VSS.n433 VSS.n366 5.2005
R639 VSS.n461 VSS.n460 5.2005
R640 VSS.n460 VSS.n459 5.2005
R641 VSS.n467 VSS.n466 4.89425
R642 VSS.n151 VSS.n150 4.34122
R643 VSS.n157 VSS.n156 4.34122
R644 VSS.n162 VSS.n161 4.34122
R645 VSS.n164 VSS.n146 4.34122
R646 VSS.n216 VSS.n86 4.34122
R647 VSS.n219 VSS.n84 4.34122
R648 VSS.n229 VSS.n90 4.34122
R649 VSS.n171 VSS.n146 4.34122
R650 VSS.n163 VSS.n162 4.34122
R651 VSS.n156 VSS.n148 4.34122
R652 VSS.n155 VSS.n150 4.34122
R653 VSS.n214 VSS.n86 4.34122
R654 VSS.n221 VSS.n84 4.34122
R655 VSS.n229 VSS.n228 4.34122
R656 VSS.n235 VSS.n234 4.34122
R657 VSS.n253 VSS.n233 4.34122
R658 VSS.n249 VSS.n232 4.34122
R659 VSS.n245 VSS.n231 4.34122
R660 VSS.n278 VSS.n48 4.34122
R661 VSS.n282 VSS.n47 4.34122
R662 VSS.n288 VSS.n50 4.34122
R663 VSS.n296 VSS.n52 4.34122
R664 VSS.n302 VSS.n301 4.34122
R665 VSS.n320 VSS.n300 4.34122
R666 VSS.n316 VSS.n299 4.34122
R667 VSS.n312 VSS.n298 4.34122
R668 VSS.n345 VSS.n12 4.34122
R669 VSS.n353 VSS.n11 4.34122
R670 VSS.n358 VSS.n10 4.34122
R671 VSS.n363 VSS.n15 4.34122
R672 VSS.n456 VSS.n455 4.34122
R673 VSS.n453 VSS.n452 4.34122
R674 VSS.n444 VSS.n438 4.34122
R675 VSS.n446 VSS.n445 4.34122
R676 VSS.n390 VSS.n380 4.34122
R677 VSS.n396 VSS.n395 4.34122
R678 VSS.n398 VSS.n386 4.34122
R679 VSS.n404 VSS.n403 4.34122
R680 VSS.n391 VSS.n390 4.34122
R681 VSS.n397 VSS.n396 4.34122
R682 VSS.n401 VSS.n386 4.34122
R683 VSS.n403 VSS.n384 4.34122
R684 VSS.n445 VSS.n8 4.34122
R685 VSS.n447 VSS.n444 4.34122
R686 VSS.n452 VSS.n451 4.34122
R687 VSS.n455 VSS.n454 4.34122
R688 VSS.n347 VSS.n12 4.34122
R689 VSS.n350 VSS.n11 4.34122
R690 VSS.n354 VSS.n10 4.34122
R691 VSS.n363 VSS.n362 4.34122
R692 VSS.n305 VSS.n298 4.34122
R693 VSS.n313 VSS.n299 4.34122
R694 VSS.n317 VSS.n300 4.34122
R695 VSS.n321 VSS.n301 4.34122
R696 VSS.n281 VSS.n48 4.34122
R697 VSS.n285 VSS.n47 4.34122
R698 VSS.n286 VSS.n50 4.34122
R699 VSS.n296 VSS.n295 4.34122
R700 VSS.n238 VSS.n231 4.34122
R701 VSS.n246 VSS.n232 4.34122
R702 VSS.n250 VSS.n233 4.34122
R703 VSS.n254 VSS.n234 4.34122
R704 VSS.n134 VSS.n130 3.72542
R705 VSS.n192 VSS.n129 3.72542
R706 VSS.n116 VSS.n114 3.72542
R707 VSS.n121 VSS.n115 3.72542
R708 VSS.n114 VSS.n111 3.72542
R709 VSS.n121 VSS.n120 3.72542
R710 VSS.n193 VSS.n192 3.72542
R711 VSS.n134 VSS.n133 3.72542
R712 VSS.n382 VSS.n377 3.59234
R713 VSS.n429 VSS.n428 3.59234
R714 VSS.n26 VSS.n22 3.59234
R715 VSS.n40 VSS.n34 3.59234
R716 VSS.n63 VSS.n59 3.59234
R717 VSS.n77 VSS.n71 3.59234
R718 VSS.n112 VSS.n96 3.59234
R719 VSS.n142 VSS.n136 3.59234
R720 VSS.n468 VSS.n467 2.98175
R721 VSS.n186 VSS.n140 0.7655
R722 VSS.n227 VSS.n92 0.7655
R723 VSS.n407 VSS.n406 0.7655
R724 VSS.n459 VSS.n458 0.7655
R725 VSS.n361 VSS.n17 0.7655
R726 VSS.n324 VSS.n32 0.7655
R727 VSS.n294 VSS.n54 0.7655
R728 VSS.n257 VSS.n69 0.7655
R729 VSS.n191 VSS.n134 0.73879
R730 VSS.n192 VSS.n191 0.73879
R731 VSS.n122 VSS.n114 0.73879
R732 VSS.n122 VSS.n121 0.73879
R733 VSS.n165 VSS.n147 0.6755
R734 VSS.n160 VSS.n147 0.6755
R735 VSS.n160 VSS.n159 0.6755
R736 VSS.n159 VSS.n158 0.6755
R737 VSS.n154 VSS.n152 0.6755
R738 VSS.n152 VSS.n140 0.6755
R739 VSS.n187 VSS.n186 0.6755
R740 VSS.n188 VSS.n187 0.6755
R741 VSS.n188 VSS.n139 0.6755
R742 VSS.n139 VSS.n98 0.6755
R743 VSS.n205 VSS.n98 0.6755
R744 VSS.n206 VSS.n205 0.6755
R745 VSS.n207 VSS.n206 0.6755
R746 VSS.n207 VSS.n92 0.6755
R747 VSS.n215 VSS.n213 0.6755
R748 VSS.n217 VSS.n215 0.6755
R749 VSS.n218 VSS.n217 0.6755
R750 VSS.n220 VSS.n218 0.6755
R751 VSS.n222 VSS.n220 0.6755
R752 VSS.n226 VSS.n225 0.6755
R753 VSS.n227 VSS.n226 0.6755
R754 VSS.n182 VSS.n181 0.6755
R755 VSS.n181 VSS.n180 0.6755
R756 VSS.n180 VSS.n179 0.6755
R757 VSS.n179 VSS.n174 0.6755
R758 VSS.n174 VSS.n173 0.6755
R759 VSS.n173 VSS.n172 0.6755
R760 VSS.n172 VSS.n94 0.6755
R761 VSS.n212 VSS.n94 0.6755
R762 VSS.n459 VSS.n433 0.6755
R763 VSS.n433 VSS.n432 0.6755
R764 VSS.n432 VSS.n368 0.6755
R765 VSS.n420 VSS.n368 0.6755
R766 VSS.n420 VSS.n419 0.6755
R767 VSS.n419 VSS.n418 0.6755
R768 VSS.n418 VSS.n375 0.6755
R769 VSS.n407 VSS.n375 0.6755
R770 VSS.n393 VSS.n379 0.6755
R771 VSS.n394 VSS.n393 0.6755
R772 VSS.n394 VSS.n389 0.6755
R773 VSS.n399 VSS.n389 0.6755
R774 VSS.n400 VSS.n399 0.6755
R775 VSS.n405 VSS.n385 0.6755
R776 VSS.n406 VSS.n405 0.6755
R777 VSS.n463 VSS.n6 0.6755
R778 VSS.n426 VSS.n6 0.6755
R779 VSS.n426 VSS.n425 0.6755
R780 VSS.n425 VSS.n424 0.6755
R781 VSS.n424 VSS.n371 0.6755
R782 VSS.n413 VSS.n371 0.6755
R783 VSS.n413 VSS.n412 0.6755
R784 VSS.n412 VSS.n411 0.6755
R785 VSS.n448 VSS.n443 0.6755
R786 VSS.n449 VSS.n448 0.6755
R787 VSS.n450 VSS.n449 0.6755
R788 VSS.n450 VSS.n437 0.6755
R789 VSS.n457 VSS.n434 0.6755
R790 VSS.n458 VSS.n457 0.6755
R791 VSS.n330 VSS.n32 0.6755
R792 VSS.n331 VSS.n330 0.6755
R793 VSS.n332 VSS.n331 0.6755
R794 VSS.n332 VSS.n24 0.6755
R795 VSS.n338 VSS.n24 0.6755
R796 VSS.n339 VSS.n338 0.6755
R797 VSS.n340 VSS.n339 0.6755
R798 VSS.n340 VSS.n17 0.6755
R799 VSS.n348 VSS.n346 0.6755
R800 VSS.n349 VSS.n348 0.6755
R801 VSS.n351 VSS.n349 0.6755
R802 VSS.n352 VSS.n351 0.6755
R803 VSS.n355 VSS.n352 0.6755
R804 VSS.n360 VSS.n359 0.6755
R805 VSS.n361 VSS.n360 0.6755
R806 VSS.n45 VSS.n44 0.6755
R807 VSS.n44 VSS.n43 0.6755
R808 VSS.n43 VSS.n39 0.6755
R809 VSS.n39 VSS.n38 0.6755
R810 VSS.n38 VSS.n37 0.6755
R811 VSS.n37 VSS.n36 0.6755
R812 VSS.n36 VSS.n21 0.6755
R813 VSS.n21 VSS.n19 0.6755
R814 VSS.n314 VSS.n311 0.6755
R815 VSS.n315 VSS.n314 0.6755
R816 VSS.n318 VSS.n315 0.6755
R817 VSS.n319 VSS.n318 0.6755
R818 VSS.n323 VSS.n322 0.6755
R819 VSS.n324 VSS.n323 0.6755
R820 VSS.n263 VSS.n69 0.6755
R821 VSS.n264 VSS.n263 0.6755
R822 VSS.n265 VSS.n264 0.6755
R823 VSS.n265 VSS.n61 0.6755
R824 VSS.n271 VSS.n61 0.6755
R825 VSS.n272 VSS.n271 0.6755
R826 VSS.n273 VSS.n272 0.6755
R827 VSS.n273 VSS.n54 0.6755
R828 VSS.n280 VSS.n279 0.6755
R829 VSS.n283 VSS.n280 0.6755
R830 VSS.n284 VSS.n283 0.6755
R831 VSS.n287 VSS.n284 0.6755
R832 VSS.n289 VSS.n287 0.6755
R833 VSS.n293 VSS.n292 0.6755
R834 VSS.n294 VSS.n293 0.6755
R835 VSS.n82 VSS.n81 0.6755
R836 VSS.n81 VSS.n80 0.6755
R837 VSS.n80 VSS.n76 0.6755
R838 VSS.n76 VSS.n75 0.6755
R839 VSS.n75 VSS.n74 0.6755
R840 VSS.n74 VSS.n73 0.6755
R841 VSS.n73 VSS.n58 0.6755
R842 VSS.n58 VSS.n56 0.6755
R843 VSS.n247 VSS.n244 0.6755
R844 VSS.n248 VSS.n247 0.6755
R845 VSS.n251 VSS.n248 0.6755
R846 VSS.n252 VSS.n251 0.6755
R847 VSS.n256 VSS.n255 0.6755
R848 VSS.n257 VSS.n256 0.6755
R849 VSS.n2 VSS.n1 0.669579
R850 VSS.n213 VSS.n212 0.5405
R851 VSS.n411 VSS.n379 0.5405
R852 VSS.n346 VSS.n19 0.5405
R853 VSS.n279 VSS.n56 0.5405
R854 VSS.n125 VSS.n110 0.5405
R855 VSS.n195 VSS.n194 0.5405
R856 VSS.n131 VSS.n106 0.5405
R857 VSS.n119 VSS.n105 0.5405
R858 VSS.n169 VSS.n165 0.50675
R859 VSS.n443 VSS.n442 0.50675
R860 VSS.n311 VSS.n310 0.50675
R861 VSS.n244 VSS.n243 0.50675
R862 VSS.n196 VSS.n195 0.4505
R863 VSS.n196 VSS.n127 0.4505
R864 VSS.n127 VSS.n126 0.4505
R865 VSS.n126 VSS.n125 0.4505
R866 VSS.n199 VSS.n106 0.4505
R867 VSS.n200 VSS.n199 0.4505
R868 VSS.n201 VSS.n200 0.4505
R869 VSS.n201 VSS.n105 0.4505
R870 VSS.n150 VSS.n144 0.430889
R871 VSS.n156 VSS.n144 0.430889
R872 VSS.n162 VSS.n144 0.430889
R873 VSS.n146 VSS.n144 0.430889
R874 VSS.n230 VSS.n86 0.430889
R875 VSS.n230 VSS.n84 0.430889
R876 VSS.n230 VSS.n229 0.430889
R877 VSS.n259 VSS.n234 0.430889
R878 VSS.n259 VSS.n233 0.430889
R879 VSS.n259 VSS.n232 0.430889
R880 VSS.n259 VSS.n231 0.430889
R881 VSS.n297 VSS.n48 0.430889
R882 VSS.n297 VSS.n47 0.430889
R883 VSS.n297 VSS.n50 0.430889
R884 VSS.n297 VSS.n296 0.430889
R885 VSS.n326 VSS.n301 0.430889
R886 VSS.n326 VSS.n300 0.430889
R887 VSS.n326 VSS.n299 0.430889
R888 VSS.n326 VSS.n298 0.430889
R889 VSS.n364 VSS.n12 0.430889
R890 VSS.n364 VSS.n11 0.430889
R891 VSS.n364 VSS.n10 0.430889
R892 VSS.n364 VSS.n363 0.430889
R893 VSS.n455 VSS.n365 0.430889
R894 VSS.n452 VSS.n365 0.430889
R895 VSS.n444 VSS.n365 0.430889
R896 VSS.n445 VSS.n365 0.430889
R897 VSS.n390 VSS.n381 0.430889
R898 VSS.n396 VSS.n381 0.430889
R899 VSS.n386 VSS.n381 0.430889
R900 VSS.n403 VSS.n381 0.430889
R901 VSS.n154 VSS.n153 0.383
R902 VSS.n225 VSS.n224 0.383
R903 VSS.n387 VSS.n385 0.383
R904 VSS.n435 VSS.n434 0.383
R905 VSS.n359 VSS.n357 0.383
R906 VSS.n322 VSS.n303 0.383
R907 VSS.n292 VSS.n291 0.383
R908 VSS.n255 VSS.n236 0.383
R909 VSS.n182 VSS.n0 0.37175
R910 VSS.n464 VSS.n463 0.37175
R911 VSS.n45 VSS.n4 0.37175
R912 VSS.n82 VSS.n3 0.37175
R913 VSS.n117 VSS.n110 0.338
R914 VSS.n118 VSS.n117 0.338
R915 VSS.n119 VSS.n118 0.338
R916 VSS.n194 VSS.n128 0.338
R917 VSS.n132 VSS.n128 0.338
R918 VSS.n132 VSS.n131 0.338
R919 VSS.n392 VSS.t92 0.2735
R920 VSS.n392 VSS.t88 0.2735
R921 VSS.n18 VSS.t78 0.2735
R922 VSS.n18 VSS.t80 0.2735
R923 VSS.n55 VSS.t66 0.2735
R924 VSS.n55 VSS.t48 0.2735
R925 VSS.n93 VSS.t58 0.2735
R926 VSS.n93 VSS.t62 0.2735
R927 VSS.n170 VSS.n0 0.16925
R928 VSS.n170 VSS.n169 0.16925
R929 VSS.n464 VSS.n5 0.16925
R930 VSS.n442 VSS.n5 0.16925
R931 VSS.n306 VSS.n4 0.16925
R932 VSS.n310 VSS.n306 0.16925
R933 VSS.n239 VSS.n3 0.16925
R934 VSS.n243 VSS.n239 0.16925
R935 VSS.n158 VSS.n149 0.158
R936 VSS.n223 VSS.n222 0.158
R937 VSS.n400 VSS.n388 0.158
R938 VSS.n437 VSS.n436 0.158
R939 VSS.n356 VSS.n355 0.158
R940 VSS.n319 VSS.n304 0.158
R941 VSS.n290 VSS.n289 0.158
R942 VSS.n252 VSS.n237 0.158
R943 VSS.n153 VSS.n149 0.1355
R944 VSS.n224 VSS.n223 0.1355
R945 VSS.n388 VSS.n387 0.1355
R946 VSS.n436 VSS.n435 0.1355
R947 VSS.n357 VSS.n356 0.1355
R948 VSS.n304 VSS.n303 0.1355
R949 VSS.n291 VSS.n290 0.1355
R950 VSS.n237 VSS.n236 0.1355
R951 VSS.n440 VSS.t86 0.1097
R952 VSS.n440 VSS.t90 0.1097
R953 VSS.n439 VSS.t82 0.1097
R954 VSS.n439 VSS.t84 0.1097
R955 VSS.n308 VSS.t74 0.1097
R956 VSS.n308 VSS.t76 0.1097
R957 VSS.n307 VSS.t46 0.1097
R958 VSS.n307 VSS.t72 0.1097
R959 VSS.n241 VSS.t68 0.1097
R960 VSS.n241 VSS.t70 0.1097
R961 VSS.n240 VSS.t60 0.1097
R962 VSS.n240 VSS.t64 0.1097
R963 VSS.n167 VSS.t54 0.1097
R964 VSS.n167 VSS.t56 0.1097
R965 VSS.n166 VSS.t50 0.1097
R966 VSS.n166 VSS.t52 0.1097
R967 VSS VSS.n468 0.05675
R968 a_41028_n400.n0 a_41028_n400.t0 16.0424
R969 a_41028_n400.n0 a_41028_n400.t1 14.8582
R970 a_41028_n400.n1 a_41028_n400.n0 5.90481
R971 a_41028_n400.n1 a_41028_n400.t3 5.67287
R972 a_41028_n400.t2 a_41028_n400.n1 5.67287
R973 a_38948_n500.n5 a_38948_n500.n3 19.8938
R974 a_38948_n500.n5 a_38948_n500.n4 19.1827
R975 a_38948_n500.n0 a_38948_n500.t7 5.85122
R976 a_38948_n500.n11 a_38948_n500.t4 5.85122
R977 a_38948_n500.n13 a_38948_n500.n12 5.74202
R978 a_38948_n500.n7 a_38948_n500.n6 4.59466
R979 a_38948_n500.n9 a_38948_n500.n8 4.58471
R980 a_38948_n500.n11 a_38948_n500.n10 4.5005
R981 a_38948_n500.n12 a_38948_n500.n1 4.5005
R982 a_38948_n500.n6 a_38948_n500.n0 4.5005
R983 a_38948_n500.n10 a_38948_n500.n9 4.5005
R984 a_38948_n500.n2 a_38948_n500.n1 4.5005
R985 a_38948_n500.n8 a_38948_n500.n7 2.22546
R986 a_38948_n500.n3 a_38948_n500.t0 0.3281
R987 a_38948_n500.n3 a_38948_n500.t1 0.3281
R988 a_38948_n500.n4 a_38948_n500.t3 0.3281
R989 a_38948_n500.n4 a_38948_n500.t2 0.3281
R990 a_38948_n500.n8 a_38948_n500.n5 0.219974
R991 a_38948_n500.n12 a_38948_n500.n11 0.189974
R992 a_38948_n500.n12 a_38948_n500.n0 0.189974
R993 a_38948_n500.n10 a_38948_n500.n1 0.189974
R994 a_38948_n500.n6 a_38948_n500.n1 0.189974
R995 a_38948_n500.n9 a_38948_n500.n2 0.189974
R996 a_38948_n500.n13 a_38948_n500.t5 0.1097
R997 a_38948_n500.t6 a_38948_n500.n13 0.1097
R998 a_38948_n500.n7 a_38948_n500.n2 0.092941
R999 a_27028_n400.n0 a_27028_n400.t0 16.0424
R1000 a_27028_n400.n0 a_27028_n400.t1 14.8582
R1001 a_27028_n400.n1 a_27028_n400.n0 5.90481
R1002 a_27028_n400.n1 a_27028_n400.t3 5.67287
R1003 a_27028_n400.t2 a_27028_n400.n1 5.67287
R1004 a_24948_n500.n5 a_24948_n500.n3 19.8938
R1005 a_24948_n500.n5 a_24948_n500.n4 19.1827
R1006 a_24948_n500.n0 a_24948_n500.t7 5.85122
R1007 a_24948_n500.n11 a_24948_n500.t4 5.85122
R1008 a_24948_n500.n13 a_24948_n500.n12 5.74202
R1009 a_24948_n500.n7 a_24948_n500.n6 4.59466
R1010 a_24948_n500.n9 a_24948_n500.n8 4.58471
R1011 a_24948_n500.n11 a_24948_n500.n10 4.5005
R1012 a_24948_n500.n12 a_24948_n500.n1 4.5005
R1013 a_24948_n500.n6 a_24948_n500.n0 4.5005
R1014 a_24948_n500.n10 a_24948_n500.n9 4.5005
R1015 a_24948_n500.n2 a_24948_n500.n1 4.5005
R1016 a_24948_n500.n8 a_24948_n500.n7 2.22546
R1017 a_24948_n500.n3 a_24948_n500.t1 0.3281
R1018 a_24948_n500.n3 a_24948_n500.t2 0.3281
R1019 a_24948_n500.n4 a_24948_n500.t0 0.3281
R1020 a_24948_n500.n4 a_24948_n500.t3 0.3281
R1021 a_24948_n500.n8 a_24948_n500.n5 0.219974
R1022 a_24948_n500.n12 a_24948_n500.n11 0.189974
R1023 a_24948_n500.n12 a_24948_n500.n0 0.189974
R1024 a_24948_n500.n10 a_24948_n500.n1 0.189974
R1025 a_24948_n500.n6 a_24948_n500.n1 0.189974
R1026 a_24948_n500.n9 a_24948_n500.n2 0.189974
R1027 a_24948_n500.n13 a_24948_n500.t5 0.1097
R1028 a_24948_n500.t6 a_24948_n500.n13 0.1097
R1029 a_24948_n500.n7 a_24948_n500.n2 0.092941
R1030 a_13028_n400.n0 a_13028_n400.t0 16.0424
R1031 a_13028_n400.n0 a_13028_n400.t1 14.8582
R1032 a_13028_n400.n1 a_13028_n400.n0 5.90481
R1033 a_13028_n400.n1 a_13028_n400.t3 5.67287
R1034 a_13028_n400.t2 a_13028_n400.n1 5.67287
R1035 a_10948_n500.n6 a_10948_n500.n4 19.8938
R1036 a_10948_n500.n6 a_10948_n500.n5 19.1827
R1037 a_10948_n500.t5 a_10948_n500.n13 5.85122
R1038 a_10948_n500.n2 a_10948_n500.t2 5.85122
R1039 a_10948_n500.n12 a_10948_n500.n1 5.74202
R1040 a_10948_n500.n7 a_10948_n500.n0 4.59466
R1041 a_10948_n500.n9 a_10948_n500.n8 4.58471
R1042 a_10948_n500.n10 a_10948_n500.n2 4.5005
R1043 a_10948_n500.n12 a_10948_n500.n11 4.5005
R1044 a_10948_n500.n13 a_10948_n500.n0 4.5005
R1045 a_10948_n500.n10 a_10948_n500.n9 4.5005
R1046 a_10948_n500.n11 a_10948_n500.n3 4.5005
R1047 a_10948_n500.n8 a_10948_n500.n7 2.22546
R1048 a_10948_n500.n4 a_10948_n500.t6 0.3281
R1049 a_10948_n500.n4 a_10948_n500.t7 0.3281
R1050 a_10948_n500.n5 a_10948_n500.t1 0.3281
R1051 a_10948_n500.n5 a_10948_n500.t0 0.3281
R1052 a_10948_n500.n8 a_10948_n500.n6 0.219974
R1053 a_10948_n500.n12 a_10948_n500.n2 0.189974
R1054 a_10948_n500.n13 a_10948_n500.n12 0.189974
R1055 a_10948_n500.n11 a_10948_n500.n10 0.189974
R1056 a_10948_n500.n11 a_10948_n500.n0 0.189974
R1057 a_10948_n500.n9 a_10948_n500.n3 0.189974
R1058 a_10948_n500.n1 a_10948_n500.t3 0.1097
R1059 a_10948_n500.n1 a_10948_n500.t4 0.1097
R1060 a_10948_n500.n7 a_10948_n500.n3 0.092941
R1061 X2.INN.n5 X2.INN.t6 96.4943
R1062 X2.INN.n0 X2.INN.t4 74.5104
R1063 X2.INN.n0 X2.INN.t5 74.5104
R1064 X2.INN.n1 X2.INN.t7 64.1282
R1065 X2.INN.n5 X2.INN.t1 31.4224
R1066 X2.INN.n1 X2.INN 28.0568
R1067 X2.INN X2.INN.n0 26.0508
R1068 X2.INN.n5 X2.INN.t0 11.0041
R1069 X2.INN.n3 X2.INN.t2 5.69917
R1070 X2.INN.n2 X2.INN.t3 5.69917
R1071 X2.INN.n2 X2.INN.n1 4.5805
R1072 X2.INN.n4 X2.INN.n3 4.5005
R1073 X2.INN.n3 X2.INN.n2 0.189974
R1074 X2.INN X2.INN.n4 0.1705
R1075 X2.INN X2.INN.n5 0.1505
R1076 X2.INN.n4 X2.INN.n1 0.0805
R1077 X2.INP.n2 X2.INP.t6 94.691
R1078 X2.INP.n0 X2.INP.t4 74.5104
R1079 X2.INP.n0 X2.INP.t5 74.5104
R1080 X2.INP.n1 X2.INP.t7 64.1282
R1081 X2.INP.n1 X2.INP 31.3779
R1082 X2.INP X2.INP.n0 26.0508
R1083 X2.INP.n2 X2.INP.t2 22.0076
R1084 X2.INP.n3 X2.INP.t3 10.9241
R1085 X2.INP.n5 X2.INP.t0 5.69917
R1086 X2.INP.n6 X2.INP.t1 5.69917
R1087 X2.INP.n3 X2.INP.n2 4.80115
R1088 X2.INP.n7 X2.INP.n6 4.5005
R1089 X2.INP.n5 X2.INP.n4 4.5005
R1090 X2.INP.n4 X2.INP.n3 0.3205
R1091 X2.INP.n6 X2.INP.n5 0.189974
R1092 X2.INP.n7 X2.INP.n1 0.0805
R1093 X2.INP.n4 X2.INP.n1 0.0805
R1094 X2.INP X2.INP.n7 0.0405
R1095 a_n972_n400.n0 a_n972_n400.t3 16.0424
R1096 a_n972_n400.n0 a_n972_n400.t0 14.8582
R1097 a_n972_n400.n1 a_n972_n400.n0 5.90481
R1098 a_n972_n400.n1 a_n972_n400.t1 5.67287
R1099 a_n972_n400.t2 a_n972_n400.n1 5.67287
R1100 XBUF.INN.n7 XBUF.INN.t6 96.4943
R1101 XBUF.INN.n0 XBUF.INN.t4 74.5104
R1102 XBUF.INN.n0 XBUF.INN.t5 74.5104
R1103 XBUF.INN.n1 XBUF.INN.t8 74.5104
R1104 XBUF.INN.n1 XBUF.INN.t9 74.5104
R1105 XBUF.INN.n3 XBUF.INN.t7 64.1282
R1106 XBUF.INN.n7 XBUF.INN.t3 31.4224
R1107 XBUF.INN.n2 XBUF.INN 28.3558
R1108 XBUF.INN XBUF.INN.n0 26.0508
R1109 XBUF.INN XBUF.INN.n1 26.0508
R1110 XBUF.INN.n2 XBUF.INN 16.9768
R1111 XBUF.INN.n3 XBUF.INN.n2 12.0068
R1112 XBUF.INN.n7 XBUF.INN.t2 11.0041
R1113 XBUF.INN.n4 XBUF.INN.t1 5.69917
R1114 XBUF.INN.n5 XBUF.INN.t0 5.69917
R1115 XBUF.INN.n4 XBUF.INN.n3 4.5805
R1116 XBUF.INN.n6 XBUF.INN.n5 4.5005
R1117 XBUF.INN.n5 XBUF.INN.n4 0.189974
R1118 XBUF.INN XBUF.INN.n6 0.1705
R1119 XBUF.INN XBUF.INN.n7 0.1505
R1120 XBUF.INN.n6 XBUF.INN.n3 0.0805
R1121 a_n3052_n500.n5 a_n3052_n500.n3 19.8938
R1122 a_n3052_n500.n5 a_n3052_n500.n4 19.1827
R1123 a_n3052_n500.n0 a_n3052_n500.t7 5.85122
R1124 a_n3052_n500.n11 a_n3052_n500.t4 5.85122
R1125 a_n3052_n500.n13 a_n3052_n500.n12 5.74202
R1126 a_n3052_n500.n7 a_n3052_n500.n6 4.59466
R1127 a_n3052_n500.n9 a_n3052_n500.n8 4.58471
R1128 a_n3052_n500.n11 a_n3052_n500.n10 4.5005
R1129 a_n3052_n500.n12 a_n3052_n500.n1 4.5005
R1130 a_n3052_n500.n6 a_n3052_n500.n0 4.5005
R1131 a_n3052_n500.n10 a_n3052_n500.n9 4.5005
R1132 a_n3052_n500.n2 a_n3052_n500.n1 4.5005
R1133 a_n3052_n500.n8 a_n3052_n500.n7 2.22546
R1134 a_n3052_n500.n3 a_n3052_n500.t1 0.3281
R1135 a_n3052_n500.n3 a_n3052_n500.t2 0.3281
R1136 a_n3052_n500.n4 a_n3052_n500.t0 0.3281
R1137 a_n3052_n500.n4 a_n3052_n500.t3 0.3281
R1138 a_n3052_n500.n8 a_n3052_n500.n5 0.219974
R1139 a_n3052_n500.n12 a_n3052_n500.n11 0.189974
R1140 a_n3052_n500.n12 a_n3052_n500.n0 0.189974
R1141 a_n3052_n500.n10 a_n3052_n500.n1 0.189974
R1142 a_n3052_n500.n6 a_n3052_n500.n1 0.189974
R1143 a_n3052_n500.n9 a_n3052_n500.n2 0.189974
R1144 a_n3052_n500.n13 a_n3052_n500.t5 0.1097
R1145 a_n3052_n500.t6 a_n3052_n500.n13 0.1097
R1146 a_n3052_n500.n7 a_n3052_n500.n2 0.092941
R1147 XBUF.INP.n4 XBUF.INP.t6 94.691
R1148 XBUF.INP.n0 XBUF.INP.t4 74.5104
R1149 XBUF.INP.n0 XBUF.INP.t5 74.5104
R1150 XBUF.INP.n1 XBUF.INP.t8 74.5104
R1151 XBUF.INP.n1 XBUF.INP.t9 74.5104
R1152 XBUF.INP.n3 XBUF.INP.t7 64.1282
R1153 XBUF.INP XBUF.INP.n0 26.0508
R1154 XBUF.INP XBUF.INP.n1 26.0508
R1155 XBUF.INP.n2 XBUF.INP 24.6873
R1156 XBUF.INP.n4 XBUF.INP.t2 22.0076
R1157 XBUF.INP.n2 XBUF.INP 20.4137
R1158 XBUF.INP.n3 XBUF.INP.n2 11.891
R1159 XBUF.INP.n5 XBUF.INP.t3 10.9241
R1160 XBUF.INP.n7 XBUF.INP.t1 5.69917
R1161 XBUF.INP.n8 XBUF.INP.t0 5.69917
R1162 XBUF.INP.n5 XBUF.INP.n4 4.80115
R1163 XBUF.INP.n9 XBUF.INP.n8 4.5005
R1164 XBUF.INP.n7 XBUF.INP.n6 4.5005
R1165 XBUF.INP.n6 XBUF.INP.n5 0.3205
R1166 XBUF.INP.n8 XBUF.INP.n7 0.189974
R1167 XBUF.INP.n9 XBUF.INP.n3 0.0805
R1168 XBUF.INP.n6 XBUF.INP.n3 0.0805
R1169 XBUF.INP XBUF.INP.n9 0.0405
R1170 XSTART.NODEN.n6 XSTART.NODEN.t7 96.4943
R1171 XSTART.NODEN.n0 XSTART.NODEN.t5 74.5104
R1172 XSTART.NODEN.n0 XSTART.NODEN.t6 74.5104
R1173 XSTART.NODEN.n2 XSTART.NODEN.t8 64.1282
R1174 XSTART.NODEN.n6 XSTART.NODEN.t0 31.4224
R1175 XSTART.NODEN XSTART.NODEN.n0 26.0508
R1176 XSTART.NODEN.n1 XSTART.NODEN 23.0937
R1177 XSTART.NODEN XSTART.NODEN.t4 19.0295
R1178 XSTART.NODEN.n6 XSTART.NODEN.t1 11.0041
R1179 XSTART.NODEN.n1 XSTART.NODEN 9.64945
R1180 XSTART.NODEN.n3 XSTART.NODEN.t3 5.69917
R1181 XSTART.NODEN.n4 XSTART.NODEN.t2 5.69917
R1182 XSTART.NODEN.n3 XSTART.NODEN.n2 4.5805
R1183 XSTART.NODEN.n5 XSTART.NODEN.n4 4.5005
R1184 XSTART.NODEN.n2 XSTART.NODEN.n1 4.5005
R1185 XSTART.NODEN.n4 XSTART.NODEN.n3 0.189974
R1186 XSTART.NODEN XSTART.NODEN.n5 0.1705
R1187 XSTART.NODEN XSTART.NODEN.n6 0.1505
R1188 XSTART.NODEN.n5 XSTART.NODEN.n2 0.0805
R1189 XSTART.NODEP.n3 XSTART.NODEP.t7 94.691
R1190 XSTART.NODEP.n0 XSTART.NODEP.t5 74.5104
R1191 XSTART.NODEP.n0 XSTART.NODEP.t6 74.5104
R1192 XSTART.NODEP.n2 XSTART.NODEP.t8 64.1282
R1193 XSTART.NODEP.n1 XSTART.NODEP 26.4147
R1194 XSTART.NODEP XSTART.NODEP.n0 26.0508
R1195 XSTART.NODEP.n3 XSTART.NODEP.t0 22.0076
R1196 XSTART.NODEP XSTART.NODEP.t4 19.1124
R1197 XSTART.NODEP.n4 XSTART.NODEP.t3 10.9241
R1198 XSTART.NODEP.n1 XSTART.NODEP 9.47182
R1199 XSTART.NODEP.n6 XSTART.NODEP.t2 5.69917
R1200 XSTART.NODEP.n7 XSTART.NODEP.t1 5.69917
R1201 XSTART.NODEP.n4 XSTART.NODEP.n3 4.80115
R1202 XSTART.NODEP.n8 XSTART.NODEP.n7 4.5005
R1203 XSTART.NODEP.n6 XSTART.NODEP.n5 4.5005
R1204 XSTART.NODEP.n2 XSTART.NODEP.n1 4.5005
R1205 XSTART.NODEP.n5 XSTART.NODEP.n4 0.3205
R1206 XSTART.NODEP.n7 XSTART.NODEP.n6 0.189974
R1207 XSTART.NODEP.n8 XSTART.NODEP.n2 0.0805
R1208 XSTART.NODEP.n5 XSTART.NODEP.n2 0.0805
R1209 XSTART.NODEP XSTART.NODEP.n8 0.0405
C0 VDD X2.INP 0.22915f
C1 CLK_N VDD 0.22915f
C2 VDD XBUF.INN 0.22915f
C3 CLK_N XBUF.INN 0.1833f
C4 XBUF.INP XSTART.NODEN 0.12139f
C5 VCTRL XSTART.NODEP 0.29405f
C6 X2.INN XSTART.NODEN 0.18691f
C7 X2.INN XBUF.INP 0.53734f
C8 CLK_P XBUF.INP 0.1833f
C9 KICKN KICKP 0.05189f
C10 KICKP XSTART.NODEP 0.0572f
C11 VCTRL X2.INP 0.43455f
C12 KICKN XSTART.NODEN 0.05896f
C13 XSTART.NODEN XSTART.NODEP 1.99103f
C14 VCTRL XBUF.INN 0.31064f
C15 XBUF.INP XSTART.NODEP 0.33192f
C16 VDD XSTART.NODEN 0.51465f
C17 XSTART.NODEN X2.INP 1.86446f
C18 XBUF.INN XSTART.NODEN 0.18933f
C19 VDD XBUF.INP 0.22915f
C20 VDD X2.INN 0.22915f
C21 XBUF.INP X2.INP 1.41645f
C22 CLK_P VDD 0.22915f
C23 X2.INN X2.INP 1.97533f
C24 CLK_N CLK_P 0.86001f
C25 XBUF.INN XBUF.INP 8.15988f
C26 X2.INN XBUF.INN 1.01104f
C27 VCTRL XSTART.NODEN 0.29712f
C28 VDD XSTART.NODEP 0.23123f
C29 X2.INP XSTART.NODEP 0.32133f
C30 VCTRL XBUF.INP 0.72416f
C31 XBUF.INN XSTART.NODEP 0.14259f
C32 VCTRL X2.INN 0.29712f
C33 CLK_N VSS 7.23721f
C34 CLK_P VSS 7.73758f
C35 VCTRL VSS 36.81002f
C36 VDD VSS 25.54118f
C37 KICKN VSS 1.20991f
C38 KICKP VSS 1.17894f
C39 X2.INN VSS 18.1557f
C40 X2.INP VSS 19.79148f
C41 XBUF.INN VSS 31.45323f
C42 XBUF.INP VSS 31.06225f
C43 XSTART.NODEN VSS 23.90314f
C44 XSTART.NODEP VSS 26.42633f
C45 XSTART.NODEP.n0 VSS 0.07563f
C46 XSTART.NODEP.t4 VSS 0.04567f
C47 XSTART.NODEP.n1 VSS 1.81282f
C48 XSTART.NODEP.n2 VSS 0.16519f
C49 XSTART.NODEP.t3 VSS 0.11401f
C50 XSTART.NODEP.t0 VSS 0.05986f
C51 XSTART.NODEP.n3 VSS 0.85546f
C52 XSTART.NODEP.n4 VSS 0.39972f
C53 XSTART.NODEP.n5 VSS 0.03896f
C54 XSTART.NODEP.t2 VSS 0.10188f
C55 XSTART.NODEP.n6 VSS 0.02866f
C56 XSTART.NODEP.t1 VSS 0.10188f
C57 XSTART.NODEP.n7 VSS 0.02866f
C58 XSTART.NODEP.n8 VSS 0.01169f
C59 XSTART.NODEN.t4 VSS 0.06018f
C60 XSTART.NODEN.n0 VSS 0.10784f
C61 XSTART.NODEN.n1 VSS 2.31695f
C62 XSTART.NODEN.n2 VSS 0.25735f
C63 XSTART.NODEN.t3 VSS 0.13262f
C64 XSTART.NODEN.n3 VSS 0.04124f
C65 XSTART.NODEN.t2 VSS 0.13262f
C66 XSTART.NODEN.n4 VSS 0.04086f
C67 XSTART.NODEN.n5 VSS 0.03472f
C68 XSTART.NODEN.t1 VSS 0.12433f
C69 XSTART.NODEN.t0 VSS 0.26546f
C70 XSTART.NODEN.n6 VSS 1.39086f
C71 XBUF.INP.n0 VSS 0.14253f
C72 XBUF.INP.n1 VSS 0.14253f
C73 XBUF.INP.n2 VSS 5.10445f
C74 XBUF.INP.n3 VSS 0.5378f
C75 XBUF.INP.t3 VSS 0.1877f
C76 XBUF.INP.t2 VSS 0.11281f
C77 XBUF.INP.n4 VSS 1.61209f
C78 XBUF.INP.n5 VSS 0.75325f
C79 XBUF.INP.n6 VSS 0.07342f
C80 XBUF.INP.t1 VSS 0.17052f
C81 XBUF.INP.n7 VSS 0.054f
C82 XBUF.INP.t0 VSS 0.17052f
C83 XBUF.INP.n8 VSS 0.054f
C84 XBUF.INP.n9 VSS 0.02203f
C85 a_n3052_n500.t5 VSS 0.13763f
C86 a_n3052_n500.t7 VSS 0.69885f
C87 a_n3052_n500.n0 VSS 0.09692f
C88 a_n3052_n500.n1 VSS 0.07066f
C89 a_n3052_n500.n2 VSS 0.07066f
C90 a_n3052_n500.t2 VSS 0.05936f
C91 a_n3052_n500.t1 VSS 0.05936f
C92 a_n3052_n500.n3 VSS 0.26259f
C93 a_n3052_n500.t3 VSS 0.06178f
C94 a_n3052_n500.t0 VSS 0.06178f
C95 a_n3052_n500.n4 VSS 0.23045f
C96 a_n3052_n500.n5 VSS 1.85814f
C97 a_n3052_n500.n6 VSS 0.0532f
C98 a_n3052_n500.n7 VSS 0.05198f
C99 a_n3052_n500.n8 VSS 0.26506f
C100 a_n3052_n500.n9 VSS 0.05307f
C101 a_n3052_n500.n10 VSS 0.05211f
C102 a_n3052_n500.t4 VSS 0.69885f
C103 a_n3052_n500.n11 VSS 0.09692f
C104 a_n3052_n500.n12 VSS 0.1048f
C105 a_n3052_n500.n13 VSS 0.52809f
C106 a_n3052_n500.t6 VSS 0.13763f
C107 XBUF.INN.n0 VSS 0.12816f
C108 XBUF.INN.n1 VSS 0.12816f
C109 XBUF.INN.n2 VSS 4.65404f
C110 XBUF.INN.n3 VSS 0.52304f
C111 XBUF.INN.t1 VSS 0.15286f
C112 XBUF.INN.n4 VSS 0.04902f
C113 XBUF.INN.t0 VSS 0.15286f
C114 XBUF.INN.n5 VSS 0.04856f
C115 XBUF.INN.n6 VSS 0.04126f
C116 XBUF.INN.t2 VSS 0.15959f
C117 XBUF.INN.t3 VSS 0.31549f
C118 XBUF.INN.n7 VSS 1.65302f
C119 a_n972_n400.t1 VSS 0.2639f
C120 a_n972_n400.t3 VSS 0.26406f
C121 a_n972_n400.t0 VSS 0.22023f
C122 a_n972_n400.n0 VSS 1.12008f
C123 a_n972_n400.n1 VSS 0.3014f
C124 a_n972_n400.t2 VSS 0.2639f
C125 X2.INP.n0 VSS 0.14109f
C126 X2.INP.n1 VSS 2.25011f
C127 X2.INP.t3 VSS 0.18479f
C128 X2.INP.t2 VSS 0.11166f
C129 X2.INP.n2 VSS 1.59579f
C130 X2.INP.n3 VSS 0.74563f
C131 X2.INP.n4 VSS 0.07268f
C132 X2.INP.t0 VSS 0.15801f
C133 X2.INP.n5 VSS 0.05345f
C134 X2.INP.t1 VSS 0.15801f
C135 X2.INP.n6 VSS 0.05345f
C136 X2.INP.n7 VSS 0.0218f
C137 X2.INN.n0 VSS 0.12405f
C138 X2.INN.n1 VSS 1.69136f
C139 X2.INN.t3 VSS 0.14589f
C140 X2.INN.n2 VSS 0.04744f
C141 X2.INN.t2 VSS 0.14589f
C142 X2.INN.n3 VSS 0.047f
C143 X2.INN.n4 VSS 0.03994f
C144 X2.INN.t0 VSS 0.15517f
C145 X2.INN.t1 VSS 0.30536f
C146 X2.INN.n5 VSS 1.59994f
C147 a_10948_n500.n0 VSS 0.05315f
C148 a_10948_n500.t4 VSS 0.13751f
C149 a_10948_n500.t3 VSS 0.13751f
C150 a_10948_n500.n1 VSS 0.52757f
C151 a_10948_n500.t2 VSS 0.69818f
C152 a_10948_n500.n2 VSS 0.09682f
C153 a_10948_n500.n3 VSS 0.07059f
C154 a_10948_n500.t7 VSS 0.0559f
C155 a_10948_n500.t6 VSS 0.0559f
C156 a_10948_n500.n4 VSS 0.26232f
C157 a_10948_n500.t0 VSS 0.05047f
C158 a_10948_n500.t1 VSS 0.05047f
C159 a_10948_n500.n5 VSS 0.23022f
C160 a_10948_n500.n6 VSS 1.85629f
C161 a_10948_n500.n7 VSS 0.05193f
C162 a_10948_n500.n8 VSS 0.26479f
C163 a_10948_n500.n9 VSS 0.05302f
C164 a_10948_n500.n10 VSS 0.05206f
C165 a_10948_n500.n11 VSS 0.07059f
C166 a_10948_n500.n12 VSS 0.10469f
C167 a_10948_n500.n13 VSS 0.09682f
C168 a_10948_n500.t5 VSS 0.69818f
C169 a_13028_n400.t3 VSS 0.2639f
C170 a_13028_n400.t0 VSS 0.26992f
C171 a_13028_n400.t1 VSS 0.23493f
C172 a_13028_n400.n0 VSS 1.12008f
C173 a_13028_n400.n1 VSS 0.3014f
C174 a_13028_n400.t2 VSS 0.2639f
C175 a_24948_n500.t5 VSS 0.13751f
C176 a_24948_n500.t7 VSS 0.69818f
C177 a_24948_n500.n0 VSS 0.09682f
C178 a_24948_n500.n1 VSS 0.07059f
C179 a_24948_n500.n2 VSS 0.07059f
C180 a_24948_n500.t2 VSS 0.05863f
C181 a_24948_n500.t1 VSS 0.05863f
C182 a_24948_n500.n3 VSS 0.26232f
C183 a_24948_n500.t3 VSS 0.0615f
C184 a_24948_n500.t0 VSS 0.0615f
C185 a_24948_n500.n4 VSS 0.23022f
C186 a_24948_n500.n5 VSS 1.85629f
C187 a_24948_n500.n6 VSS 0.05315f
C188 a_24948_n500.n7 VSS 0.05193f
C189 a_24948_n500.n8 VSS 0.26479f
C190 a_24948_n500.n9 VSS 0.05302f
C191 a_24948_n500.n10 VSS 0.05206f
C192 a_24948_n500.t4 VSS 0.69818f
C193 a_24948_n500.n11 VSS 0.09682f
C194 a_24948_n500.n12 VSS 0.10469f
C195 a_24948_n500.n13 VSS 0.52757f
C196 a_24948_n500.t6 VSS 0.13751f
C197 a_27028_n400.t3 VSS 0.2639f
C198 a_27028_n400.t0 VSS 0.27141f
C199 a_27028_n400.t1 VSS 0.23525f
C200 a_27028_n400.n0 VSS 1.12008f
C201 a_27028_n400.n1 VSS 0.3014f
C202 a_27028_n400.t2 VSS 0.2639f
C203 a_38948_n500.t5 VSS 0.13371f
C204 a_38948_n500.t7 VSS 0.67557f
C205 a_38948_n500.n0 VSS 0.09357f
C206 a_38948_n500.n1 VSS 0.06822f
C207 a_38948_n500.n2 VSS 0.06822f
C208 a_38948_n500.t1 VSS 0.05805f
C209 a_38948_n500.t0 VSS 0.05805f
C210 a_38948_n500.n3 VSS 0.25352f
C211 a_38948_n500.t2 VSS 0.06047f
C212 a_38948_n500.t3 VSS 0.06047f
C213 a_38948_n500.n4 VSS 0.22249f
C214 a_38948_n500.n5 VSS 1.79398f
C215 a_38948_n500.n6 VSS 0.05136f
C216 a_38948_n500.n7 VSS 0.05019f
C217 a_38948_n500.n8 VSS 0.2559f
C218 a_38948_n500.n9 VSS 0.05124f
C219 a_38948_n500.n10 VSS 0.05031f
C220 a_38948_n500.t4 VSS 0.67557f
C221 a_38948_n500.n11 VSS 0.09357f
C222 a_38948_n500.n12 VSS 0.10118f
C223 a_38948_n500.n13 VSS 0.50986f
C224 a_38948_n500.t6 VSS 0.13371f
C225 a_41028_n400.t3 VSS 0.26271f
C226 a_41028_n400.t0 VSS 0.27935f
C227 a_41028_n400.t1 VSS 0.23356f
C228 a_41028_n400.n0 VSS 1.1148f
C229 a_41028_n400.n1 VSS 0.29998f
C230 a_41028_n400.t2 VSS 0.26271f
C231 VSS.t97 VSS 0.01049f
C232 VSS.t94 VSS 0.01033f
C233 VSS.t80 VSS 0.0104f
C234 VSS.t78 VSS 0.0104f
C235 VSS.t48 VSS 0.0104f
C236 VSS.t66 VSS 0.0104f
C237 VSS.t62 VSS 0.0104f
C238 VSS.t58 VSS 0.0104f
C239 VSS.t18 VSS 0.0185f
C240 VSS.t19 VSS 0.0185f
C241 VSS.t52 VSS 0.02431f
C242 VSS.t50 VSS 0.02453f
C243 VSS.t56 VSS 0.02453f
C244 VSS.t54 VSS 0.02431f
C245 VSS.t24 VSS 0.02637f
C246 VSS.t23 VSS 0.02637f
C247 VSS.t37 VSS 0.03451f
C248 VSS.t36 VSS 0.03451f
C249 VSS.t64 VSS 0.02431f
C250 VSS.t60 VSS 0.02453f
C251 VSS.t70 VSS 0.02453f
C252 VSS.t68 VSS 0.02431f
C253 VSS.t22 VSS 0.03034f
C254 VSS.t21 VSS 0.03034f
C255 VSS.t29 VSS 0.03486f
C256 VSS.t28 VSS 0.03486f
C257 VSS.t72 VSS 0.02431f
C258 VSS.t46 VSS 0.02453f
C259 VSS.t76 VSS 0.02453f
C260 VSS.t74 VSS 0.02431f
C261 VSS.t14 VSS 0.03134f
C262 VSS.t13 VSS 0.03134f
C263 VSS.t31 VSS 0.03743f
C264 VSS.t32 VSS 0.03743f
C265 VSS.t88 VSS 0.0104f
C266 VSS.t92 VSS 0.0104f
C267 VSS.t43 VSS 0.03406f
C268 VSS.t42 VSS 0.03406f
C269 VSS.t84 VSS 0.02431f
C270 VSS.t82 VSS 0.02453f
C271 VSS.t90 VSS 0.02453f
C272 VSS.t86 VSS 0.02431f
C273 VDD.t3 VSS 0.013f
C274 VDD.n0 VSS 0.46134f
C275 VDD.n1 VSS 0.2802f
C276 VDD.n2 VSS 0.21319f
C277 VDD.t0 VSS 0.013f
C278 VDD.n3 VSS 0.46134f
C279 VDD.n4 VSS 0.2802f
C280 VDD.n5 VSS 0.18954f
C281 VCTRL.n0 VSS 0.04326f
C282 VCTRL.n1 VSS 0.02f
C283 VCTRL.n2 VSS 0.02104f
C284 VCTRL.n3 VSS 0.02104f
C285 VCTRL.n4 VSS 0.02f
C286 VCTRL.n5 VSS 0.10812f
C287 VCTRL.n6 VSS 0.46624f
C288 VCTRL.n7 VSS 0.04326f
C289 VCTRL.n8 VSS 0.02f
C290 VCTRL.n9 VSS 0.02104f
C291 VCTRL.n10 VSS 0.02104f
C292 VCTRL.n11 VSS 0.02f
C293 VCTRL.n12 VSS 0.10812f
C294 VCTRL.n13 VSS 0.04326f
C295 VCTRL.n14 VSS 0.02f
C296 VCTRL.n15 VSS 0.02104f
C297 VCTRL.n16 VSS 0.02104f
C298 VCTRL.n17 VSS 0.02f
C299 VCTRL.n18 VSS 0.10812f
C300 VCTRL.n19 VSS 0.04326f
C301 VCTRL.n20 VSS 0.02f
C302 VCTRL.n21 VSS 0.02104f
C303 VCTRL.n22 VSS 0.02104f
C304 VCTRL.n23 VSS 0.02f
C305 VCTRL.n24 VSS 0.10812f
C306 VCTRL.n25 VSS 1.1909f
C307 VCTRL.n26 VSS 1.22514f
C308 VCTRL.n27 VSS 1.1909f
C309 CLK_P.n0 VSS 0.30415f
C310 CLK_P.t1 VSS 0.1674f
C311 CLK_P.t0 VSS 0.19346f
C312 CLK_P.t3 VSS 0.11022f
C313 CLK_P.n1 VSS 1.5751f
C314 CLK_P.n2 VSS 0.73597f
C315 CLK_P.n3 VSS 0.07173f
C316 CLK_P.n4 VSS 0.05276f
C317 CLK_P.t2 VSS 0.1674f
C318 CLK_P.n5 VSS 0.05276f
C319 CLK_P.n6 VSS 0.01793f
C320 CLK_N.n0 VSS 0.36528f
C321 CLK_N.t3 VSS 0.17919f
C322 CLK_N.n1 VSS 0.05854f
C323 CLK_N.t1 VSS 0.17919f
C324 CLK_N.n2 VSS 0.05799f
C325 CLK_N.n3 VSS 0.04928f
C326 CLK_N.t0 VSS 0.18364f
C327 CLK_N.t2 VSS 0.37679f
C328 CLK_N.n4 VSS 1.97418f
.ends
