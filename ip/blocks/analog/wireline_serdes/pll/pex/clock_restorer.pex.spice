* PEX produced on Thu Aug 20 12:51:44 AM CEST 2026 using /foss/tools/sak/sak-pex.sh with m=3 and s=1 (extresist threshold=0 mOhm, minres=1 mOhm, mindelay=0 ps)
* NGSPICE file created from cml_clock_restorer_pex.ext - technology: gf180mcuD

.subckt cml_clock_restorer_pex IN_P IN_N VBIAS VDD VSS OUT_P OUT_N
X0 VDD.t1 OUT_P.t0 VSS.t1 ppolyf_u r_width=2u r_length=7.5u
X1 VSS.t5 VBIAS.t1 a_n852_n600.t2 VSS.t4 nfet_03v3 ad=3.12p pd=12.52u as=3.12p ps=12.52u w=12u l=0.28u
X2 a_n852_n600.t6 IN_P.t1 OUT_P.t1 VSS.t12 nfet_03v3 ad=2.6p pd=10.52u as=4.4p ps=20.88u w=10u l=0.28u
X3 OUT_N.t1 IN_N.t0 a_n852_n600.t5 VSS.t11 nfet_03v3 ad=4.4p pd=20.88u as=2.6p ps=10.52u w=10u l=0.28u
X4 a_n852_n600.t1 VBIAS.t2 VSS.t7 VSS.t6 nfet_03v3 ad=3.12p pd=12.52u as=3.12p ps=12.52u w=12u l=0.28u
X5 OUT_P.t2 IN_P.t0 a_n852_n600.t7 VSS.t13 nfet_03v3 ad=4.4p pd=20.88u as=2.6p ps=10.52u w=10u l=0.28u
X6 a_n852_n600.t3 VBIAS.t0 VSS.t9 VSS.t8 nfet_03v3 ad=5.28p pd=24.88u as=3.12p ps=12.52u w=12u l=0.28u
X7 a_n852_n600.t4 IN_N.t1 OUT_N.t2 VSS.t10 nfet_03v3 ad=2.6p pd=10.52u as=4.4p ps=20.88u w=10u l=0.28u
X8 VDD.t0 OUT_N.t0 VSS.t0 ppolyf_u r_width=2u r_length=7.5u
X9 VSS.t3 VBIAS.t3 a_n852_n600.t0 VSS.t2 nfet_03v3 ad=3.12p pd=12.52u as=5.28p ps=24.88u w=12u l=0.28u
R0 VBIAS.n0 VBIAS.t0 165.774
R1 VBIAS.n3 VBIAS.t3 165.774
R2 VBIAS.n1 VBIAS.t1 161.317
R3 VBIAS.n2 VBIAS.t2 161.317
R4 VBIAS VBIAS.n4 13.7729
R5 VBIAS.n2 VBIAS.n1 11.6805
R6 VBIAS.n4 VBIAS.n0 7.10487
R7 VBIAS.n4 VBIAS.n3 7.10487
R8 VBIAS.n1 VBIAS.n0 4.42851
R9 VBIAS.n3 VBIAS.n2 4.42851
R10 IN_N.n0 IN_N.t1 139.689
R11 IN_N.n0 IN_N.t0 139.689
R12 IN_N IN_N.n0 25.9192
R13 IN_P.n0 IN_P.t1 139.689
R14 IN_P.n0 IN_P.t0 139.689
R15 IN_P IN_P.n0 25.9192
R16 OUT_N OUT_N.t0 12.48
R17 OUT_N.n0 OUT_N.t1 6.0613
R18 OUT_N.n0 OUT_N.t2 6.0613
R19 OUT_N OUT_N.n0 2.70032
R20 OUT_P OUT_P.t0 12.48
R21 OUT_P.n0 OUT_P.t2 6.0613
R22 OUT_P.n0 OUT_P.t1 6.0613
R23 OUT_P OUT_P.n0 2.70032
R24 VDD VDD.t0 21.6022
R25 VDD VDD.t1 21.5133
R26 VSS.n65 VSS.n17 325
R27 VSS.n80 VSS.n4 282.61
R28 VSS.n23 VSS.n17 227.5
R29 VSS.n80 VSS.n79 183.696
R30 VSS.n46 VSS.t12 97.5005
R31 VSS.t10 VSS.n49 97.5005
R32 VSS.n46 VSS.n4 86.1961
R33 VSS.t2 VSS.n47 72.0657
R34 VSS.n49 VSS.t8 72.0657
R35 VSS.n66 VSS.n14 59.5005
R36 VSS.t6 VSS.t2 56.5222
R37 VSS.t4 VSS.t6 56.5222
R38 VSS.n47 VSS.n45 55.1092
R39 VSS.n50 VSS.n23 55.1092
R40 VSS.n77 VSS.n9 52.5005
R41 VSS.n33 VSS.n32 52.5005
R42 VSS.n37 VSS.n36 52.5005
R43 VSS.n66 VSS.n13 52.5005
R44 VSS.n56 VSS.n55 52.5005
R45 VSS.n58 VSS.n18 52.5005
R46 VSS.n19 VSS.n18 52.5005
R47 VSS.t13 VSS.n45 42.3918
R48 VSS.n48 VSS.t4 42.3918
R49 VSS.n50 VSS.t11 42.3918
R50 VSS.n81 VSS.n3 42.0005
R51 VSS.n63 VSS.n20 42.0005
R52 VSS.n81 VSS.n2 35.0005
R53 VSS.n29 VSS.n2 35.0005
R54 VSS.n29 VSS.n25 35.0005
R55 VSS.n25 VSS.n24 35.0005
R56 VSS.n24 VSS.n14 35.0005
R57 VSS.n30 VSS.n5 35.0005
R58 VSS.n44 VSS.n30 35.0005
R59 VSS.n44 VSS.n22 35.0005
R60 VSS.n51 VSS.n22 35.0005
R61 VSS.n51 VSS.n20 35.0005
R62 VSS.t12 VSS.t1 28.2614
R63 VSS.t1 VSS.t13 28.2614
R64 VSS.t0 VSS.t10 28.2614
R65 VSS.t11 VSS.t0 28.2614
R66 VSS.n39 VSS.n5 24.5005
R67 VSS VSS.n83 18.8227
R68 VSS.t8 VSS.n48 14.1309
R69 VSS.n75 VSS.n74 10.2705
R70 VSS.n69 VSS.n68 10.2705
R71 VSS.n71 VSS.n70 6.5388
R72 VSS.n73 VSS.n72 6.5388
R73 VSS.n40 VSS.n39 5.2005
R74 VSS.n38 VSS.n37 5.2005
R75 VSS.n36 VSS.n35 5.2005
R76 VSS.n34 VSS.n33 5.2005
R77 VSS.n32 VSS.n31 5.2005
R78 VSS.n10 VSS.n9 5.2005
R79 VSS.n77 VSS.n76 5.2005
R80 VSS.n3 VSS.n0 5.2005
R81 VSS.n80 VSS.n5 5.2005
R82 VSS.n41 VSS.n5 5.2005
R83 VSS.n30 VSS.n4 5.2005
R84 VSS.n42 VSS.n30 5.2005
R85 VSS.n45 VSS.n44 5.2005
R86 VSS.n44 VSS.n43 5.2005
R87 VSS.n48 VSS.n22 5.2005
R88 VSS.n22 VSS.n21 5.2005
R89 VSS.n51 VSS.n50 5.2005
R90 VSS.n52 VSS.n51 5.2005
R91 VSS.n20 VSS.n17 5.2005
R92 VSS.n53 VSS.n20 5.2005
R93 VSS.n66 VSS.n65 5.2005
R94 VSS.n67 VSS.n66 5.2005
R95 VSS.n13 VSS.n11 5.2005
R96 VSS.n55 VSS.n54 5.2005
R97 VSS.n57 VSS.n56 5.2005
R98 VSS.n59 VSS.n58 5.2005
R99 VSS.n65 VSS.n18 5.2005
R100 VSS.n60 VSS.n18 5.2005
R101 VSS.n61 VSS.n19 5.2005
R102 VSS.n63 VSS.n62 5.2005
R103 VSS.n17 VSS.n14 5.2005
R104 VSS.n14 VSS.n12 5.2005
R105 VSS.n50 VSS.n24 5.2005
R106 VSS.n26 VSS.n24 5.2005
R107 VSS.n48 VSS.n25 5.2005
R108 VSS.n27 VSS.n25 5.2005
R109 VSS.n45 VSS.n29 5.2005
R110 VSS.n29 VSS.n28 5.2005
R111 VSS.n4 VSS.n2 5.2005
R112 VSS.n2 VSS.n1 5.2005
R113 VSS.n81 VSS.n80 5.2005
R114 VSS.n82 VSS.n81 5.2005
R115 VSS.n74 VSS.n73 4.5005
R116 VSS.n71 VSS.n69 4.5005
R117 VSS.n39 VSS.n6 4.34122
R118 VSS.n36 VSS.n7 4.34122
R119 VSS.n32 VSS.n8 4.34122
R120 VSS.n78 VSS.n77 4.34122
R121 VSS.n16 VSS.n13 4.34122
R122 VSS.n56 VSS.n15 4.34122
R123 VSS.n64 VSS.n19 4.34122
R124 VSS.n78 VSS.n3 4.34122
R125 VSS.n9 VSS.n8 4.34122
R126 VSS.n33 VSS.n7 4.34122
R127 VSS.n37 VSS.n6 4.34122
R128 VSS.n55 VSS.n16 4.34122
R129 VSS.n58 VSS.n15 4.34122
R130 VSS.n64 VSS.n63 4.34122
R131 VSS.n49 VSS.n23 3.58947
R132 VSS.n47 VSS.n46 3.58947
R133 VSS.n67 VSS.n12 0.7655
R134 VSS.n76 VSS.n10 0.6755
R135 VSS.n31 VSS.n10 0.6755
R136 VSS.n34 VSS.n31 0.6755
R137 VSS.n35 VSS.n34 0.6755
R138 VSS.n38 VSS.n35 0.6755
R139 VSS.n40 VSS.n38 0.6755
R140 VSS.n54 VSS.n11 0.6755
R141 VSS.n57 VSS.n54 0.6755
R142 VSS.n59 VSS.n57 0.6755
R143 VSS.n60 VSS.n59 0.6755
R144 VSS.n61 VSS.n60 0.6755
R145 VSS.n62 VSS.n61 0.6755
R146 VSS.n62 VSS.n53 0.5405
R147 VSS.n42 VSS.n41 0.4505
R148 VSS.n43 VSS.n42 0.4505
R149 VSS.n43 VSS.n21 0.4505
R150 VSS.n52 VSS.n21 0.4505
R151 VSS.n53 VSS.n52 0.4505
R152 VSS.n82 VSS.n1 0.4505
R153 VSS.n28 VSS.n1 0.4505
R154 VSS.n28 VSS.n27 0.4505
R155 VSS.n27 VSS.n26 0.4505
R156 VSS.n26 VSS.n12 0.4505
R157 VSS.n79 VSS.n6 0.430889
R158 VSS.n79 VSS.n7 0.430889
R159 VSS.n79 VSS.n8 0.430889
R160 VSS.n79 VSS.n78 0.430889
R161 VSS.n65 VSS.n16 0.430889
R162 VSS.n65 VSS.n15 0.430889
R163 VSS.n65 VSS.n64 0.430889
R164 VSS.n83 VSS.n82 0.37175
R165 VSS.n75 VSS.n0 0.366125
R166 VSS.n68 VSS.n67 0.366125
R167 VSS.n41 VSS.n40 0.3155
R168 VSS.n76 VSS.n75 0.309875
R169 VSS.n68 VSS.n11 0.309875
R170 VSS.n73 VSS.n71 0.189974
R171 VSS.n83 VSS.n0 0.16925
R172 VSS.n74 VSS.n69 0.1605
R173 VSS.n70 VSS.t5 0.137
R174 VSS.n70 VSS.t9 0.137
R175 VSS.n72 VSS.t3 0.137
R176 VSS.n72 VSS.t7 0.137
R177 a_n852_n600.n5 a_n852_n600.n3 10.7042
R178 a_n852_n600.n5 a_n852_n600.n4 10.7042
R179 a_n852_n600.t3 a_n852_n600.n7 6.77
R180 a_n852_n600.n2 a_n852_n600.t0 6.6753
R181 a_n852_n600.n1 a_n852_n600.n0 6.5388
R182 a_n852_n600.n6 a_n852_n600.n2 4.63668
R183 a_n852_n600.n7 a_n852_n600.n6 2.23814
R184 a_n852_n600.n6 a_n852_n600.n5 0.5055
R185 a_n852_n600.n2 a_n852_n600.n1 0.189974
R186 a_n852_n600.n3 a_n852_n600.t4 0.1643
R187 a_n852_n600.n3 a_n852_n600.t5 0.1643
R188 a_n852_n600.n4 a_n852_n600.t6 0.1643
R189 a_n852_n600.n4 a_n852_n600.t7 0.1643
R190 a_n852_n600.n0 a_n852_n600.t1 0.137
R191 a_n852_n600.n0 a_n852_n600.t2 0.137
R192 a_n852_n600.n7 a_n852_n600.n1 0.0924286
C0 VDD OUT_N 0.02488f
C1 OUT_N OUT_P 0.16184f
C2 VDD OUT_P 0.02488f
C3 IN_N IN_P 0.28517f
C4 IN_N VBIAS 0.04176f
C5 IN_P VBIAS 0.04176f
C6 IN_N OUT_N 0.24744f
C7 IN_P OUT_P 0.24744f
C8 VBIAS VSS 2.0607f
C9 IN_N VSS 2.16941f
C10 IN_P VSS 2.16941f
C11 OUT_N VSS 2.76565f
C12 OUT_P VSS 2.76565f
C13 VDD VSS 3.27637f
C14 a_n852_n600.t2 VSS 0.17674f
C15 a_n852_n600.t1 VSS 0.17674f
C16 a_n852_n600.n0 VSS 0.49363f
C17 a_n852_n600.n1 VSS 0.14089f
C18 a_n852_n600.t0 VSS 0.71176f
C19 a_n852_n600.n2 VSS 0.1262f
C20 a_n852_n600.t5 VSS 0.16233f
C21 a_n852_n600.t4 VSS 0.16233f
C22 a_n852_n600.n3 VSS 0.45925f
C23 a_n852_n600.t7 VSS 0.16233f
C24 a_n852_n600.t6 VSS 0.16233f
C25 a_n852_n600.n4 VSS 0.45925f
C26 a_n852_n600.n5 VSS 0.96184f
C27 a_n852_n600.n6 VSS 0.42491f
C28 a_n852_n600.n7 VSS 0.12444f
C29 a_n852_n600.t3 VSS 0.71352f
C30 VSS.t9 VSS 0.04188f
C31 VSS.t5 VSS 0.04139f
C32 VSS.t7 VSS 0.04139f
C33 VSS.t3 VSS 0.04188f
C34 OUT_P.t0 VSS 0.16688f
C35 OUT_P.t1 VSS 0.62373f
C36 OUT_P.t2 VSS 0.62373f
C37 OUT_P.n0 VSS 0.29451f
C38 OUT_N.t0 VSS 0.16688f
C39 OUT_N.t2 VSS 0.62373f
C40 OUT_N.t1 VSS 0.62373f
C41 OUT_N.n0 VSS 0.29451f
C42 IN_P.n0 VSS 0.16589f
C43 IN_N.n0 VSS 0.16589f
C44 VBIAS.n0 VSS 0.03558f
C45 VBIAS.n1 VSS 0.0378f
C46 VBIAS.n2 VSS 0.0378f
C47 VBIAS.n3 VSS 0.03558f
C48 VBIAS.n4 VSS 0.09569f
.ends
