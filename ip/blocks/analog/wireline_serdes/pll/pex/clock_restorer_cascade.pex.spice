* PEX produced on Thu Aug 20 12:36:24 AM CEST 2026 using /foss/tools/sak/sak-pex.sh with m=3 and s=1 (extresist threshold=0 mOhm, minres=1 mOhm, mindelay=0 ps)
* NGSPICE file created from cml_clock_restorer_cascade_pex.ext - technology: gf180mcuD

.subckt cml_clock_restorer_cascade_pex IN_P IN_N VBIAS VDD VSS OUT_P OUT_N
X0 VDD.t3 OUT_P.t2 VSS.t4 ppolyf_u r_width=2u r_length=7.5u
X1 OUT_P.t0 a_n1000_2348.t3 a_n852_8800.t1 VSS.t1 nfet_03v3 ad=4.4p pd=20.88u as=2.6p ps=10.52u w=10u l=0.28u
X2 VSS.t11 VBIAS.t5 a_n852_8800.t6 VSS.t10 nfet_03v3 ad=3.12p pd=12.52u as=3.12p ps=12.52u w=12u l=0.28u
X3 a_n852_8800.t7 VBIAS.t4 VSS.t9 VSS.t8 nfet_03v3 ad=5.28p pd=24.88u as=3.12p ps=12.52u w=12u l=0.28u
X4 VDD.t0 a_n1000_2348.t0 VSS.t4 ppolyf_u r_width=2u r_length=7.5u
X5 a_n852_8800.t0 a_600_2348.t4 OUT_N.t0 VSS.t0 nfet_03v3 ad=2.6p pd=10.52u as=4.4p ps=20.88u w=10u l=0.28u
X6 VDD.t2 OUT_N.t2 VSS.t17 ppolyf_u r_width=2u r_length=7.5u
X7 VSS.t6 VBIAS.t7 a_n852_8800.t4 VSS.t5 nfet_03v3 ad=3.12p pd=12.52u as=5.28p ps=24.88u w=12u l=0.28u
X8 VSS.t14 VBIAS.t1 a_n852_n600.t2 VSS.t10 nfet_03v3 ad=3.12p pd=12.52u as=3.12p ps=12.52u w=12u l=0.28u
X9 a_n852_8800.t5 VBIAS.t6 VSS.t13 VSS.t12 nfet_03v3 ad=3.12p pd=12.52u as=3.12p ps=12.52u w=12u l=0.28u
X10 a_n852_n600.t7 IN_P.t1 a_n1000_2348.t1 VSS.t2 nfet_03v3 ad=2.6p pd=10.52u as=4.4p ps=20.88u w=10u l=0.28u
X11 a_600_2348.t2 IN_N.t0 a_n852_n600.t4 VSS.t3 nfet_03v3 ad=4.4p pd=20.88u as=2.6p ps=10.52u w=10u l=0.28u
X12 a_n852_n600.t1 VBIAS.t2 VSS.t15 VSS.t12 nfet_03v3 ad=3.12p pd=12.52u as=3.12p ps=12.52u w=12u l=0.28u
X13 a_n1000_2348.t2 IN_P.t0 a_n852_n600.t6 VSS.t1 nfet_03v3 ad=4.4p pd=20.88u as=2.6p ps=10.52u w=10u l=0.28u
X14 a_n852_n600.t3 VBIAS.t0 VSS.t16 VSS.t8 nfet_03v3 ad=5.28p pd=24.88u as=3.12p ps=12.52u w=12u l=0.28u
X15 a_n852_8800.t2 a_n1000_2348.t4 OUT_P.t1 VSS.t2 nfet_03v3 ad=2.6p pd=10.52u as=4.4p ps=20.88u w=10u l=0.28u
X16 a_n852_n600.t5 IN_N.t1 a_600_2348.t1 VSS.t0 nfet_03v3 ad=2.6p pd=10.52u as=4.4p ps=20.88u w=10u l=0.28u
X17 OUT_N.t1 a_600_2348.t3 a_n852_8800.t3 VSS.t3 nfet_03v3 ad=4.4p pd=20.88u as=2.6p ps=10.52u w=10u l=0.28u
X18 VDD.t1 a_600_2348.t0 VSS.t17 ppolyf_u r_width=2u r_length=7.5u
X19 VSS.t7 VBIAS.t3 a_n852_n600.t0 VSS.t5 nfet_03v3 ad=3.12p pd=12.52u as=5.28p ps=24.88u w=12u l=0.28u
R0 IN_N.n0 IN_N.t1 139.689
R1 IN_N.n0 IN_N.t0 139.689
R2 IN_N IN_N.n0 25.9192
R3 IN_P.n0 IN_P.t1 139.689
R4 IN_P.n0 IN_P.t0 139.689
R5 IN_P IN_P.n0 25.9192
R6 VBIAS.n8 VBIAS.t3 165.774
R7 VBIAS.n5 VBIAS.t0 165.774
R8 VBIAS.n0 VBIAS.t4 165.774
R9 VBIAS.n3 VBIAS.t7 165.774
R10 VBIAS.n6 VBIAS.t1 161.317
R11 VBIAS.n7 VBIAS.t2 161.317
R12 VBIAS.n1 VBIAS.t5 161.317
R13 VBIAS.n2 VBIAS.t6 161.317
R14 VBIAS.n10 VBIAS.n4 19.0663
R15 VBIAS.n10 VBIAS.n9 13.5005
R16 VBIAS.n7 VBIAS.n6 11.6805
R17 VBIAS.n2 VBIAS.n1 11.6805
R18 VBIAS.n9 VBIAS.n5 7.10487
R19 VBIAS.n9 VBIAS.n8 7.10487
R20 VBIAS.n4 VBIAS.n0 7.10487
R21 VBIAS.n4 VBIAS.n3 7.10487
R22 VBIAS.n6 VBIAS.n5 4.42851
R23 VBIAS.n8 VBIAS.n7 4.42851
R24 VBIAS.n1 VBIAS.n0 4.42851
R25 VBIAS.n3 VBIAS.n2 4.42851
R26 VBIAS VBIAS.n10 0.272868
R27 OUT_N OUT_N.t2 12.48
R28 OUT_N.n0 OUT_N.t1 6.0613
R29 OUT_N.n0 OUT_N.t0 6.0613
R30 OUT_N OUT_N.n0 2.70032
R31 OUT_P OUT_P.t2 12.48
R32 OUT_P.n0 OUT_P.t0 6.0613
R33 OUT_P.n0 OUT_P.t1 6.0613
R34 OUT_P OUT_P.n0 2.70032
R35 VDD.n1 VDD.t3 21.7356
R36 VDD.n0 VDD.t0 21.7356
R37 VDD.n1 VDD.t2 21.38
R38 VDD.n0 VDD.t1 21.38
R39 VDD VDD.n0 2.30717
R40 VDD VDD.n1 0.218278
R41 VSS.n131 VSS.n24 160.754
R42 VSS.n152 VSS.n5 139.786
R43 VSS.n56 VSS.n24 112.528
R44 VSS.n152 VSS.n151 90.8607
R45 VSS.n132 VSS.n22 59.5005
R46 VSS.n60 VSS.n59 59.5005
R47 VSS.n142 VSS.n4 52.5005
R48 VSS.n146 VSS.n145 52.5005
R49 VSS.n150 VSS.n17 52.5005
R50 VSS.n150 VSS.n16 52.5005
R51 VSS.n132 VSS.n21 52.5005
R52 VSS.n44 VSS.n26 52.5005
R53 VSS.n47 VSS.n26 52.5005
R54 VSS.n51 VSS.n50 52.5005
R55 VSS.n119 VSS.n118 52.5005
R56 VSS.n123 VSS.n122 52.5005
R57 VSS.n125 VSS.n31 52.5005
R58 VSS.n105 VSS.n104 52.5005
R59 VSS.n101 VSS.n100 52.5005
R60 VSS.n97 VSS.n96 52.5005
R61 VSS.t2 VSS.n40 48.2263
R62 VSS.t0 VSS.n74 48.2263
R63 VSS.n40 VSS.n5 42.6349
R64 VSS.n153 VSS.n4 42.0005
R65 VSS.n55 VSS.n54 42.0005
R66 VSS.n107 VSS.n7 42.0005
R67 VSS.n129 VSS.n32 42.0005
R68 VSS.t5 VSS.n37 35.6457
R69 VSS.n74 VSS.t8 35.6457
R70 VSS.n153 VSS.n3 35.0005
R71 VSS.n39 VSS.n3 35.0005
R72 VSS.n72 VSS.n39 35.0005
R73 VSS.n72 VSS.n58 35.0005
R74 VSS.n58 VSS.n22 35.0005
R75 VSS.n42 VSS.n8 35.0005
R76 VSS.n87 VSS.n42 35.0005
R77 VSS.n87 VSS.n41 35.0005
R78 VSS.n79 VSS.n41 35.0005
R79 VSS.n79 VSS.n55 35.0005
R80 VSS.n64 VSS.n7 35.0005
R81 VSS.n64 VSS.n38 35.0005
R82 VSS.n68 VSS.n38 35.0005
R83 VSS.n68 VSS.n57 35.0005
R84 VSS.n60 VSS.n57 35.0005
R85 VSS.n90 VSS.n6 35.0005
R86 VSS.n90 VSS.n89 35.0005
R87 VSS.n89 VSS.n36 35.0005
R88 VSS.n77 VSS.n36 35.0005
R89 VSS.n77 VSS.n32 35.0005
R90 VSS.t12 VSS.t5 27.9575
R91 VSS.t10 VSS.t12 27.9575
R92 VSS.n88 VSS.n37 27.2586
R93 VSS.n78 VSS.n56 27.2586
R94 VSS.n82 VSS.n8 24.5005
R95 VSS.n93 VSS.n6 24.5005
R96 VSS.n88 VSS.t1 20.9682
R97 VSS.n73 VSS.t10 20.9682
R98 VSS.n78 VSS.t3 20.9682
R99 VSS VSS.n0 19.2672
R100 VSS VSS.n155 18.8227
R101 VSS.t4 VSS.t2 13.979
R102 VSS.t1 VSS.t4 13.979
R103 VSS.t17 VSS.t0 13.979
R104 VSS.t3 VSS.t17 13.979
R105 VSS.n141 VSS.n140 10.2705
R106 VSS.n116 VSS.n115 10.2705
R107 VSS.n110 VSS.n109 10.2705
R108 VSS.n135 VSS.n134 10.2705
R109 VSS.t8 VSS.n73 6.98975
R110 VSS.n114 VSS.n111 6.5388
R111 VSS.n113 VSS.n112 6.5388
R112 VSS.n137 VSS.n136 6.5388
R113 VSS.n139 VSS.n138 6.5388
R114 VSS.n83 VSS.n82 5.2005
R115 VSS.n18 VSS.n16 5.2005
R116 VSS.n151 VSS.n150 5.2005
R117 VSS.n150 VSS.n149 5.2005
R118 VSS.n148 VSS.n17 5.2005
R119 VSS.n147 VSS.n146 5.2005
R120 VSS.n145 VSS.n144 5.2005
R121 VSS.n143 VSS.n142 5.2005
R122 VSS.n151 VSS.n4 5.2005
R123 VSS.n4 VSS.n1 5.2005
R124 VSS.n55 VSS.n24 5.2005
R125 VSS.n55 VSS.n43 5.2005
R126 VSS.n79 VSS.n78 5.2005
R127 VSS.n80 VSS.n79 5.2005
R128 VSS.n73 VSS.n41 5.2005
R129 VSS.n81 VSS.n41 5.2005
R130 VSS.n88 VSS.n87 5.2005
R131 VSS.n87 VSS.n86 5.2005
R132 VSS.n42 VSS.n5 5.2005
R133 VSS.n85 VSS.n42 5.2005
R134 VSS.n152 VSS.n8 5.2005
R135 VSS.n84 VSS.n8 5.2005
R136 VSS.n132 VSS.n131 5.2005
R137 VSS.n133 VSS.n132 5.2005
R138 VSS.n21 VSS.n19 5.2005
R139 VSS.n45 VSS.n44 5.2005
R140 VSS.n131 VSS.n26 5.2005
R141 VSS.n46 VSS.n26 5.2005
R142 VSS.n48 VSS.n47 5.2005
R143 VSS.n50 VSS.n49 5.2005
R144 VSS.n52 VSS.n51 5.2005
R145 VSS.n54 VSS.n53 5.2005
R146 VSS.n24 VSS.n22 5.2005
R147 VSS.n22 VSS.n20 5.2005
R148 VSS.n78 VSS.n58 5.2005
R149 VSS.n69 VSS.n58 5.2005
R150 VSS.n73 VSS.n72 5.2005
R151 VSS.n72 VSS.n71 5.2005
R152 VSS.n88 VSS.n39 5.2005
R153 VSS.n70 VSS.n39 5.2005
R154 VSS.n5 VSS.n3 5.2005
R155 VSS.n3 VSS.n2 5.2005
R156 VSS.n153 VSS.n152 5.2005
R157 VSS.n154 VSS.n153 5.2005
R158 VSS.n152 VSS.n6 5.2005
R159 VSS.n92 VSS.n6 5.2005
R160 VSS.n90 VSS.n5 5.2005
R161 VSS.n91 VSS.n90 5.2005
R162 VSS.n89 VSS.n88 5.2005
R163 VSS.n89 VSS.n35 5.2005
R164 VSS.n73 VSS.n36 5.2005
R165 VSS.n75 VSS.n36 5.2005
R166 VSS.n78 VSS.n77 5.2005
R167 VSS.n77 VSS.n76 5.2005
R168 VSS.n32 VSS.n24 5.2005
R169 VSS.n33 VSS.n32 5.2005
R170 VSS.n60 VSS.n24 5.2005
R171 VSS.n61 VSS.n60 5.2005
R172 VSS.n78 VSS.n57 5.2005
R173 VSS.n62 VSS.n57 5.2005
R174 VSS.n73 VSS.n68 5.2005
R175 VSS.n68 VSS.n67 5.2005
R176 VSS.n88 VSS.n38 5.2005
R177 VSS.n66 VSS.n38 5.2005
R178 VSS.n64 VSS.n5 5.2005
R179 VSS.n65 VSS.n64 5.2005
R180 VSS.n152 VSS.n7 5.2005
R181 VSS.n63 VSS.n7 5.2005
R182 VSS.n94 VSS.n93 5.2005
R183 VSS.n96 VSS.n95 5.2005
R184 VSS.n98 VSS.n97 5.2005
R185 VSS.n100 VSS.n99 5.2005
R186 VSS.n102 VSS.n101 5.2005
R187 VSS.n104 VSS.n103 5.2005
R188 VSS.n106 VSS.n105 5.2005
R189 VSS.n108 VSS.n107 5.2005
R190 VSS.n59 VSS.n34 5.2005
R191 VSS.n118 VSS.n117 5.2005
R192 VSS.n120 VSS.n119 5.2005
R193 VSS.n122 VSS.n121 5.2005
R194 VSS.n124 VSS.n123 5.2005
R195 VSS.n126 VSS.n125 5.2005
R196 VSS.n127 VSS.n31 5.2005
R197 VSS.n129 VSS.n128 5.2005
R198 VSS.n113 VSS.n110 4.5005
R199 VSS.n115 VSS.n114 4.5005
R200 VSS.n140 VSS.n139 4.5005
R201 VSS.n137 VSS.n135 4.5005
R202 VSS.n82 VSS.n13 4.34122
R203 VSS.n17 VSS.n15 4.34122
R204 VSS.n145 VSS.n14 4.34122
R205 VSS.n44 VSS.n25 4.34122
R206 VSS.n47 VSS.n27 4.34122
R207 VSS.n51 VSS.n28 4.34122
R208 VSS.n142 VSS.n14 4.34122
R209 VSS.n146 VSS.n15 4.34122
R210 VSS.n16 VSS.n13 4.34122
R211 VSS.n25 VSS.n21 4.34122
R212 VSS.n50 VSS.n27 4.34122
R213 VSS.n54 VSS.n28 4.34122
R214 VSS.n93 VSS.n9 4.34122
R215 VSS.n97 VSS.n10 4.34122
R216 VSS.n101 VSS.n11 4.34122
R217 VSS.n105 VSS.n12 4.34122
R218 VSS.n118 VSS.n23 4.34122
R219 VSS.n119 VSS.n29 4.34122
R220 VSS.n123 VSS.n30 4.34122
R221 VSS.n130 VSS.n31 4.34122
R222 VSS.n59 VSS.n23 4.34122
R223 VSS.n122 VSS.n29 4.34122
R224 VSS.n125 VSS.n30 4.34122
R225 VSS.n130 VSS.n129 4.34122
R226 VSS.n107 VSS.n12 4.34122
R227 VSS.n104 VSS.n11 4.34122
R228 VSS.n100 VSS.n10 4.34122
R229 VSS.n96 VSS.n9 4.34122
R230 VSS.n74 VSS.n56 1.79498
R231 VSS.n40 VSS.n37 1.79498
R232 VSS.n133 VSS.n20 0.7655
R233 VSS.n61 VSS.n34 0.7655
R234 VSS.n144 VSS.n143 0.6755
R235 VSS.n147 VSS.n144 0.6755
R236 VSS.n148 VSS.n147 0.6755
R237 VSS.n149 VSS.n148 0.6755
R238 VSS.n149 VSS.n18 0.6755
R239 VSS.n83 VSS.n18 0.6755
R240 VSS.n45 VSS.n19 0.6755
R241 VSS.n46 VSS.n45 0.6755
R242 VSS.n48 VSS.n46 0.6755
R243 VSS.n49 VSS.n48 0.6755
R244 VSS.n52 VSS.n49 0.6755
R245 VSS.n53 VSS.n52 0.6755
R246 VSS.n120 VSS.n117 0.6755
R247 VSS.n121 VSS.n120 0.6755
R248 VSS.n124 VSS.n121 0.6755
R249 VSS.n126 VSS.n124 0.6755
R250 VSS.n127 VSS.n126 0.6755
R251 VSS.n128 VSS.n127 0.6755
R252 VSS.n106 VSS.n103 0.6755
R253 VSS.n103 VSS.n102 0.6755
R254 VSS.n102 VSS.n99 0.6755
R255 VSS.n99 VSS.n98 0.6755
R256 VSS.n98 VSS.n95 0.6755
R257 VSS.n95 VSS.n94 0.6755
R258 VSS.n53 VSS.n43 0.5405
R259 VSS.n128 VSS.n33 0.5405
R260 VSS.n85 VSS.n84 0.4505
R261 VSS.n86 VSS.n85 0.4505
R262 VSS.n86 VSS.n81 0.4505
R263 VSS.n81 VSS.n80 0.4505
R264 VSS.n80 VSS.n43 0.4505
R265 VSS.n154 VSS.n2 0.4505
R266 VSS.n70 VSS.n2 0.4505
R267 VSS.n71 VSS.n70 0.4505
R268 VSS.n71 VSS.n69 0.4505
R269 VSS.n69 VSS.n20 0.4505
R270 VSS.n65 VSS.n63 0.4505
R271 VSS.n66 VSS.n65 0.4505
R272 VSS.n67 VSS.n66 0.4505
R273 VSS.n67 VSS.n62 0.4505
R274 VSS.n62 VSS.n61 0.4505
R275 VSS.n92 VSS.n91 0.4505
R276 VSS.n91 VSS.n35 0.4505
R277 VSS.n75 VSS.n35 0.4505
R278 VSS.n76 VSS.n75 0.4505
R279 VSS.n76 VSS.n33 0.4505
R280 VSS.n151 VSS.n13 0.430889
R281 VSS.n151 VSS.n15 0.430889
R282 VSS.n151 VSS.n14 0.430889
R283 VSS.n131 VSS.n25 0.430889
R284 VSS.n131 VSS.n27 0.430889
R285 VSS.n131 VSS.n28 0.430889
R286 VSS.n151 VSS.n9 0.430889
R287 VSS.n151 VSS.n10 0.430889
R288 VSS.n151 VSS.n11 0.430889
R289 VSS.n151 VSS.n12 0.430889
R290 VSS.n131 VSS.n23 0.430889
R291 VSS.n131 VSS.n29 0.430889
R292 VSS.n131 VSS.n30 0.430889
R293 VSS.n131 VSS.n130 0.430889
R294 VSS.n155 VSS.n154 0.37175
R295 VSS.n63 VSS.n0 0.37175
R296 VSS.n141 VSS.n1 0.366125
R297 VSS.n134 VSS.n133 0.366125
R298 VSS.n116 VSS.n34 0.366125
R299 VSS.n109 VSS.n108 0.366125
R300 VSS.n84 VSS.n83 0.3155
R301 VSS.n94 VSS.n92 0.3155
R302 VSS.n143 VSS.n141 0.309875
R303 VSS.n134 VSS.n19 0.309875
R304 VSS.n117 VSS.n116 0.309875
R305 VSS.n109 VSS.n106 0.309875
R306 VSS.n114 VSS.n113 0.189974
R307 VSS.n139 VSS.n137 0.189974
R308 VSS.n155 VSS.n1 0.16925
R309 VSS.n108 VSS.n0 0.16925
R310 VSS.n115 VSS.n110 0.1605
R311 VSS.n140 VSS.n135 0.1605
R312 VSS.n111 VSS.t11 0.137
R313 VSS.n111 VSS.t9 0.137
R314 VSS.n112 VSS.t6 0.137
R315 VSS.n112 VSS.t13 0.137
R316 VSS.n136 VSS.t14 0.137
R317 VSS.n136 VSS.t16 0.137
R318 VSS.n138 VSS.t7 0.137
R319 VSS.n138 VSS.t15 0.137
R320 a_n852_n600.n5 a_n852_n600.n3 10.7042
R321 a_n852_n600.n5 a_n852_n600.n4 10.7042
R322 a_n852_n600.t3 a_n852_n600.n7 6.77
R323 a_n852_n600.n2 a_n852_n600.t0 6.6753
R324 a_n852_n600.n1 a_n852_n600.n0 6.5388
R325 a_n852_n600.n6 a_n852_n600.n2 4.63668
R326 a_n852_n600.n7 a_n852_n600.n6 2.23814
R327 a_n852_n600.n6 a_n852_n600.n5 0.5055
R328 a_n852_n600.n2 a_n852_n600.n1 0.189974
R329 a_n852_n600.n3 a_n852_n600.t5 0.1643
R330 a_n852_n600.n3 a_n852_n600.t4 0.1643
R331 a_n852_n600.n4 a_n852_n600.t7 0.1643
R332 a_n852_n600.n4 a_n852_n600.t6 0.1643
R333 a_n852_n600.n0 a_n852_n600.t1 0.137
R334 a_n852_n600.n0 a_n852_n600.t2 0.137
R335 a_n852_n600.n7 a_n852_n600.n1 0.0924286
R336 a_n852_8800.n3 a_n852_8800.n1 10.7042
R337 a_n852_8800.n3 a_n852_8800.n2 10.7042
R338 a_n852_8800.n0 a_n852_8800.t7 6.77
R339 a_n852_8800.n5 a_n852_8800.t4 6.6753
R340 a_n852_8800.n7 a_n852_8800.n6 6.5388
R341 a_n852_8800.n5 a_n852_8800.n4 4.63668
R342 a_n852_8800.n4 a_n852_8800.n0 2.23814
R343 a_n852_8800.n4 a_n852_8800.n3 0.5055
R344 a_n852_8800.n6 a_n852_8800.n5 0.189974
R345 a_n852_8800.n1 a_n852_8800.t0 0.1643
R346 a_n852_8800.n1 a_n852_8800.t3 0.1643
R347 a_n852_8800.n2 a_n852_8800.t2 0.1643
R348 a_n852_8800.n2 a_n852_8800.t1 0.1643
R349 a_n852_8800.n7 a_n852_8800.t5 0.137
R350 a_n852_8800.t6 a_n852_8800.n7 0.137
R351 a_n852_8800.n6 a_n852_8800.n0 0.0924286
R352 a_600_2348.n0 a_600_2348.t4 139.689
R353 a_600_2348.n0 a_600_2348.t3 139.689
R354 a_600_2348.n1 a_600_2348.n0 37.2961
R355 a_600_2348.n1 a_600_2348.t0 12.392
R356 a_600_2348.n2 a_600_2348.t1 6.0613
R357 a_600_2348.t2 a_600_2348.n2 6.0613
R358 a_600_2348.n2 a_600_2348.n1 2.78832
R359 a_n1000_2348.n0 a_n1000_2348.t4 139.689
R360 a_n1000_2348.n0 a_n1000_2348.t3 139.689
R361 a_n1000_2348.n1 a_n1000_2348.n0 37.2961
R362 a_n1000_2348.n1 a_n1000_2348.t0 12.392
R363 a_n1000_2348.n2 a_n1000_2348.t1 6.0613
R364 a_n1000_2348.t2 a_n1000_2348.n2 6.0613
R365 a_n1000_2348.n2 a_n1000_2348.n1 2.78832
C0 OUT_P VDD 0.02488f
C1 VDD VBIAS 0.20024f
C2 IN_P IN_N 0.27707f
C3 OUT_N OUT_P 0.16184f
C4 OUT_N VDD 0.07929f
C5 IN_P VBIAS 0.11346f
C6 IN_N VBIAS 0.11346f
C7 IN_N VSS 2.1911f
C8 IN_P VSS 2.1911f
C9 VBIAS VSS 6.05203f
C10 OUT_N VSS 2.78304f
C11 OUT_P VSS 2.76565f
C12 VDD VSS 9.38841f
C13 a_n1000_2348.t1 VSS 0.43732f
C14 a_n1000_2348.t0 VSS 0.11079f
C15 a_n1000_2348.n0 VSS 0.62354f
C16 a_n1000_2348.n1 VSS 1.90628f
C17 a_n1000_2348.n2 VSS 0.20816f
C18 a_n1000_2348.t2 VSS 0.43732f
C19 a_600_2348.t1 VSS 0.48406f
C20 a_600_2348.t0 VSS 0.12423f
C21 a_600_2348.n0 VSS 0.69915f
C22 a_600_2348.n1 VSS 2.1374f
C23 a_600_2348.n2 VSS 0.2334f
C24 a_600_2348.t2 VSS 0.48406f
C25 a_n852_8800.t5 VSS 0.18548f
C26 a_n852_8800.t7 VSS 0.72426f
C27 a_n852_8800.n0 VSS 0.12487f
C28 a_n852_8800.t3 VSS 0.18727f
C29 a_n852_8800.t0 VSS 0.18727f
C30 a_n852_8800.n1 VSS 0.46086f
C31 a_n852_8800.t1 VSS 0.17926f
C32 a_n852_8800.t2 VSS 0.17926f
C33 a_n852_8800.n2 VSS 0.46086f
C34 a_n852_8800.n3 VSS 0.96523f
C35 a_n852_8800.n4 VSS 0.42641f
C36 a_n852_8800.t4 VSS 0.72248f
C37 a_n852_8800.n5 VSS 0.12665f
C38 a_n852_8800.n6 VSS 0.14138f
C39 a_n852_8800.n7 VSS 0.49537f
C40 a_n852_8800.t6 VSS 0.18548f
C41 a_n852_n600.t2 VSS 0.19979f
C42 a_n852_n600.t1 VSS 0.19979f
C43 a_n852_n600.n0 VSS 0.54754f
C44 a_n852_n600.n1 VSS 0.15627f
C45 a_n852_n600.t0 VSS 0.79328f
C46 a_n852_n600.n2 VSS 0.13999f
C47 a_n852_n600.t4 VSS 0.17687f
C48 a_n852_n600.t5 VSS 0.17687f
C49 a_n852_n600.n3 VSS 0.5094f
C50 a_n852_n600.t6 VSS 0.17687f
C51 a_n852_n600.t7 VSS 0.17687f
C52 a_n852_n600.n4 VSS 0.5094f
C53 a_n852_n600.n5 VSS 1.06689f
C54 a_n852_n600.n6 VSS 0.47132f
C55 a_n852_n600.n7 VSS 0.13803f
C56 a_n852_n600.t3 VSS 0.79524f
C57 VSS.t9 VSS 0.05025f
C58 VSS.t11 VSS 0.04966f
C59 VSS.t13 VSS 0.04966f
C60 VSS.t6 VSS 0.05025f
C61 VSS.t16 VSS 0.05025f
C62 VSS.t14 VSS 0.04966f
C63 VSS.t15 VSS 0.04966f
C64 VSS.t7 VSS 0.05025f
C65 VDD.t0 VSS 0.04536f
C66 VDD.t1 VSS 0.04293f
C67 VDD.n0 VSS 0.54072f
C68 VDD.t3 VSS 0.04536f
C69 VDD.t2 VSS 0.04293f
C70 VDD.n1 VSS 0.25229f
C71 OUT_P.t2 VSS 0.16688f
C72 OUT_P.t1 VSS 0.64026f
C73 OUT_P.t0 VSS 0.64026f
C74 OUT_P.n0 VSS 0.29451f
C75 OUT_N.t2 VSS 0.17072f
C76 OUT_N.t0 VSS 0.66147f
C77 OUT_N.t1 VSS 0.66147f
C78 OUT_N.n0 VSS 0.30129f
C79 VBIAS.n0 VSS 0.04269f
C80 VBIAS.n1 VSS 0.04535f
C81 VBIAS.n2 VSS 0.04535f
C82 VBIAS.n3 VSS 0.04269f
C83 VBIAS.n4 VSS 0.32186f
C84 VBIAS.n5 VSS 0.04269f
C85 VBIAS.n6 VSS 0.04535f
C86 VBIAS.n7 VSS 0.04535f
C87 VBIAS.n8 VSS 0.04269f
C88 VBIAS.n9 VSS 0.1135f
C89 VBIAS.n10 VSS 1.24081f
C90 IN_P.n0 VSS 0.17332f
C91 IN_N.n0 VSS 0.17332f
.ends
