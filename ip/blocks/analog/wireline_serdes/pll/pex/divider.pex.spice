* PEX produced on Wed Aug 19 11:17:04 PM CEST 2026 using /foss/tools/sak/sak-pex.sh with m=3 and s=1 (extresist threshold=0 mOhm, minres=1 mOhm, mindelay=0 ps)
* NGSPICE file created from cml_divider_by_2_pex.ext - technology: gf180mcuD

.subckt cml_divider_by_2_pex CLK_P CLK_N RESET VBIAS VDD VSS DIV_P DIV_N
X0 a_n7396_200.t1 a_n5720_0.t9 a_n5652_200.t1 VSS.t2 nfet_03v3 ad=2.64p pd=12.88u as=1.56p ps=6.52u w=6u l=0.28u
X1 a_n5720_0.t6 RESET.t2 VSS.t23 VSS.t22 nfet_03v3 ad=0.88p pd=4.88u as=0.52p ps=2.52u w=2u l=0.28u
X2 DIV_P.t6 RESET.t0 VSS.t27 VSS.t26 nfet_03v3 ad=0.88p pd=4.88u as=0.52p ps=2.52u w=2u l=0.28u
X3 a_n6052_n2400.t5 CLK_N.t3 a_n5652_200.t4 VSS.t44 nfet_03v3 ad=2.08p pd=8.52u as=3.52p ps=16.88u w=8u l=0.28u
X4 a_3548_n2400.t6 CLK_P.t1 a_3948_200.t4 VSS.t50 nfet_03v3 ad=2.08p pd=8.52u as=3.52p ps=16.88u w=8u l=0.28u
X5 a_3548_n2400.t3 VBIAS.t0 VSS.t43 VSS.t42 nfet_03v3 ad=4.4p pd=20.88u as=2.6p ps=10.52u w=10u l=0.28u
X6 VSS.t37 VBIAS.t3 a_3548_n2400.t0 VSS.t36 nfet_03v3 ad=2.6p pd=10.52u as=4.4p ps=20.88u w=10u l=0.28u
X7 a_n7252_200.t3 DIV_P.t10 a_n7396_200.t3 VSS.t13 nfet_03v3 ad=1.56p pd=6.52u as=2.64p ps=12.88u w=6u l=0.28u
X8 a_n6052_n2400.t1 VBIAS.t6 VSS.t33 VSS.t32 nfet_03v3 ad=2.6p pd=10.52u as=2.6p ps=10.52u w=10u l=0.28u
X9 a_3948_200.t2 DIV_P.t8 DIV_N.t3 VSS.t15 nfet_03v3 ad=1.56p pd=6.52u as=2.64p ps=12.88u w=6u l=0.28u
X10 a_n5652_200.t5 CLK_N.t2 a_n6052_n2400.t4 VSS.t45 nfet_03v3 ad=3.52p pd=16.88u as=2.08p ps=8.52u w=8u l=0.28u
X11 VSS.t25 RESET.t1 DIV_P.t5 VSS.t24 nfet_03v3 ad=0.52p pd=2.52u as=0.88p ps=4.88u w=2u l=0.28u
X12 a_2348_200.t5 CLK_N.t0 a_3548_n2400.t5 VSS.t47 nfet_03v3 ad=3.52p pd=16.88u as=2.08p ps=8.52u w=8u l=0.28u
X13 a_n5720_0.t4 a_n7396_200.t7 a_n5652_200.t3 VSS.t18 nfet_03v3 ad=2.64p pd=12.88u as=1.56p ps=6.52u w=6u l=0.28u
X14 VDD.t2 DIV_P.t1 VSS.t6 ppolyf_u r_width=2u r_length=7.5u
X15 a_n5720_0.t2 DIV_N.t7 a_n7252_200.t1 VSS.t9 nfet_03v3 ad=2.64p pd=12.88u as=1.56p ps=6.52u w=6u l=0.28u
X16 VSS.t29 VBIAS.t5 a_n6052_n2400.t2 VSS.t28 nfet_03v3 ad=2.6p pd=10.52u as=2.6p ps=10.52u w=10u l=0.28u
X17 VSS.t41 VBIAS.t1 a_3548_n2400.t2 VSS.t40 nfet_03v3 ad=2.6p pd=10.52u as=2.6p ps=10.52u w=10u l=0.28u
X18 DIV_N.t4 a_n7396_200.t5 a_2348_200.t3 VSS.t19 nfet_03v3 ad=2.64p pd=12.88u as=1.56p ps=6.52u w=6u l=0.28u
X19 a_n5652_200.t0 a_n5720_0.t10 a_n7396_200.t0 VSS.t1 nfet_03v3 ad=1.56p pd=6.52u as=2.64p ps=12.88u w=6u l=0.28u
X20 a_3548_n2400.t4 CLK_N.t1 a_2348_200.t4 VSS.t46 nfet_03v3 ad=2.08p pd=8.52u as=3.52p ps=16.88u w=8u l=0.28u
X21 a_n5652_200.t2 a_n7396_200.t8 a_n5720_0.t3 VSS.t12 nfet_03v3 ad=1.56p pd=6.52u as=2.64p ps=12.88u w=6u l=0.28u
X22 VSS.t31 VBIAS.t7 a_n6052_n2400.t0 VSS.t30 nfet_03v3 ad=2.6p pd=10.52u as=4.4p ps=20.88u w=10u l=0.28u
X23 a_3948_200.t0 DIV_N.t6 DIV_P.t3 VSS.t10 nfet_03v3 ad=1.56p pd=6.52u as=2.64p ps=12.88u w=6u l=0.28u
X24 a_n6052_n2400.t6 CLK_P.t3 a_n7252_200.t4 VSS.t48 nfet_03v3 ad=2.08p pd=8.52u as=3.52p ps=16.88u w=8u l=0.28u
X25 a_2348_200.t2 a_n5720_0.t8 DIV_P.t4 VSS.t17 nfet_03v3 ad=1.56p pd=6.52u as=2.64p ps=12.88u w=6u l=0.28u
X26 a_n6052_n2400.t3 VBIAS.t4 VSS.t35 VSS.t34 nfet_03v3 ad=4.4p pd=20.88u as=2.6p ps=10.52u w=10u l=0.28u
X27 a_3548_n2400.t1 VBIAS.t2 VSS.t39 VSS.t38 nfet_03v3 ad=2.6p pd=10.52u as=2.6p ps=10.52u w=10u l=0.28u
X28 VDD.t0 DIV_N.t2 VSS.t4 ppolyf_u r_width=2u r_length=7.5u
X29 VDD.t3 a_n5720_0.t0 VSS.t7 ppolyf_u r_width=2u r_length=7.5u
X30 DIV_N.t1 DIV_P.t7 a_3948_200.t3 VSS.t16 nfet_03v3 ad=2.64p pd=12.88u as=1.56p ps=6.52u w=6u l=0.28u
X31 DIV_P.t2 DIV_N.t5 a_3948_200.t1 VSS.t11 nfet_03v3 ad=2.64p pd=12.88u as=1.56p ps=6.52u w=6u l=0.28u
X32 a_n7396_200.t4 DIV_P.t9 a_n7252_200.t2 VSS.t14 nfet_03v3 ad=2.64p pd=12.88u as=1.56p ps=6.52u w=6u l=0.28u
X33 a_3948_200.t5 CLK_P.t0 a_3548_n2400.t7 VSS.t51 nfet_03v3 ad=3.52p pd=16.88u as=2.08p ps=8.52u w=8u l=0.28u
X34 a_n7252_200.t0 DIV_N.t8 a_n5720_0.t1 VSS.t8 nfet_03v3 ad=1.56p pd=6.52u as=2.64p ps=12.88u w=6u l=0.28u
X35 VSS.t21 RESET.t3 a_n5720_0.t5 VSS.t20 nfet_03v3 ad=0.52p pd=2.52u as=0.88p ps=4.88u w=2u l=0.28u
X36 a_n7252_200.t5 CLK_P.t2 a_n6052_n2400.t7 VSS.t49 nfet_03v3 ad=3.52p pd=16.88u as=2.08p ps=8.52u w=8u l=0.28u
X37 VDD.t1 a_n7396_200.t2 VSS.t5 ppolyf_u r_width=2u r_length=7.5u
X38 a_2348_200.t0 a_n7396_200.t6 DIV_N.t0 VSS.t0 nfet_03v3 ad=1.56p pd=6.52u as=2.64p ps=12.88u w=6u l=0.28u
X39 DIV_P.t0 a_n5720_0.t7 a_2348_200.t1 VSS.t3 nfet_03v3 ad=2.64p pd=12.88u as=1.56p ps=6.52u w=6u l=0.28u
R0 RESET.n1 RESET.t2 35.4171
R1 RESET.n0 RESET.t1 35.4171
R2 RESET.n1 RESET.t3 35.3883
R3 RESET.n0 RESET.t0 35.3883
R4 RESET.n2 RESET.n1 25.8112
R5 RESET.n2 RESET.n0 25.8112
R6 RESET RESET.n2 0.259447
R7 VBIAS.n3 VBIAS.t3 139.702
R8 VBIAS.n0 VBIAS.t0 139.702
R9 VBIAS.n5 VBIAS.t4 139.702
R10 VBIAS.n8 VBIAS.t7 139.702
R11 VBIAS.n1 VBIAS.t1 135.246
R12 VBIAS.n2 VBIAS.t2 135.246
R13 VBIAS.n6 VBIAS.t5 135.246
R14 VBIAS.n7 VBIAS.t6 135.246
R15 VBIAS.n10 VBIAS.n4 19.1847
R16 VBIAS.n10 VBIAS.n9 13.5005
R17 VBIAS.n2 VBIAS.n1 11.6805
R18 VBIAS.n7 VBIAS.n6 11.6805
R19 VBIAS.n4 VBIAS.n0 7.10487
R20 VBIAS.n4 VBIAS.n3 7.10487
R21 VBIAS.n9 VBIAS.n5 7.10487
R22 VBIAS.n9 VBIAS.n8 7.10487
R23 VBIAS.n1 VBIAS.n0 4.42851
R24 VBIAS.n3 VBIAS.n2 4.42851
R25 VBIAS.n6 VBIAS.n5 4.42851
R26 VBIAS.n8 VBIAS.n7 4.42851
R27 VBIAS.n11 VBIAS.n10 1.30313
R28 VBIAS.n11 VBIAS 0.109447
R29 VBIAS VBIAS.n11 0.0455
R30 CLK_N.n1 CLK_N.t1 113.618
R31 CLK_N.n1 CLK_N.t0 113.618
R32 CLK_N.n0 CLK_N.t3 113.618
R33 CLK_N.n0 CLK_N.t2 113.618
R34 CLK_N.n2 CLK_N.n1 25.1703
R35 CLK_N.n2 CLK_N.n0 20.9071
R36 CLK_N CLK_N.n2 3.27129
R37 CLK_P.n1 CLK_P.t1 113.618
R38 CLK_P.n1 CLK_P.t0 113.618
R39 CLK_P.n0 CLK_P.t3 113.618
R40 CLK_P.n0 CLK_P.t2 113.618
R41 CLK_P.n2 CLK_P.n1 28.3203
R42 CLK_P.n2 CLK_P.n0 25.1624
R43 CLK_P CLK_P.n2 0.9805
R44 DIV_N.n2 DIV_N.t5 87.5461
R45 DIV_N.n2 DIV_N.t6 87.5461
R46 DIV_N.n1 DIV_N.t7 87.5461
R47 DIV_N.n1 DIV_N.t8 87.5461
R48 DIV_N.n9 DIV_N.n1 31.3365
R49 DIV_N.n3 DIV_N.n2 26.3217
R50 DIV_N DIV_N.t2 12.48
R51 DIV_N.n0 DIV_N.t4 5.96544
R52 DIV_N.n0 DIV_N.t0 5.9622
R53 DIV_N.n6 DIV_N.t1 5.87051
R54 DIV_N.n5 DIV_N.t3 5.87051
R55 DIV_N.n5 DIV_N.n4 4.5005
R56 DIV_N.n7 DIV_N.n6 4.5005
R57 DIV_N.n9 DIV_N.n0 2.56391
R58 DIV_N DIV_N.n9 0.7305
R59 DIV_N.n8 DIV_N.n3 0.419
R60 DIV_N.n9 DIV_N.n8 0.2415
R61 DIV_N.n6 DIV_N.n5 0.189974
R62 DIV_N.n7 DIV_N.n4 0.1605
R63 DIV_N.n8 DIV_N.n7 0.0795
R64 DIV_N.n4 DIV_N.n3 0.0740593
R65 DIV_P.n0 DIV_P.t7 87.5461
R66 DIV_P.n0 DIV_P.t8 87.5461
R67 DIV_P.n8 DIV_P.t9 87.5461
R68 DIV_P.n8 DIV_P.t10 87.5461
R69 DIV_P.n10 DIV_P.n8 38.3766
R70 DIV_P.n1 DIV_P.n0 35.3132
R71 DIV_P DIV_P.t1 12.48
R72 DIV_P.n2 DIV_P.t5 7.21035
R73 DIV_P.n2 DIV_P.t6 7.20745
R74 DIV_P.n9 DIV_P.t4 5.96544
R75 DIV_P.n9 DIV_P.t0 5.9622
R76 DIV_P.n7 DIV_P.n2 5.94824
R77 DIV_P.n4 DIV_P.t2 5.87051
R78 DIV_P.n5 DIV_P.t3 5.87051
R79 DIV_P.n6 DIV_P.n5 4.5005
R80 DIV_P.n4 DIV_P.n3 4.5005
R81 DIV_P.n10 DIV_P.n9 2.56391
R82 DIV_P DIV_P.n10 0.7305
R83 DIV_P.n7 DIV_P.n1 0.419
R84 DIV_P.n10 DIV_P.n7 0.2415
R85 DIV_P.n5 DIV_P.n4 0.189974
R86 DIV_P.n6 DIV_P.n3 0.1605
R87 DIV_P.n7 DIV_P.n6 0.0795
R88 DIV_P.n3 DIV_P.n1 0.0405
R89 VDD.n1 VDD.t1 22.0211
R90 VDD.n0 VDD.t0 22.0211
R91 VDD.n1 VDD.t3 21.31
R92 VDD.n0 VDD.t2 21.31
R93 VDD VDD.n0 0.756056
R94 VDD VDD.n1 0.667167
R95 VSS.n149 VSS.n4 354.546
R96 VSS.n77 VSS.n39 354.546
R97 VSS.n96 VSS.n20 354.546
R98 VSS.t22 VSS.n39 271.818
R99 VSS.t24 VSS.n77 271.818
R100 VSS.n149 VSS.n148 153.637
R101 VSS.t13 VSS.n4 153.637
R102 VSS.n71 VSS.t9 153.637
R103 VSS.n78 VSS.t17 153.637
R104 VSS.n96 VSS.t19 153.637
R105 VSS.n113 VSS.n20 153.637
R106 VSS.n61 VSS.t14 107.546
R107 VSS.t8 VSS.n70 107.546
R108 VSS.n86 VSS.t3 107.546
R109 VSS.t0 VSS.n95 107.546
R110 VSS.n59 VSS.t30 106.365
R111 VSS.n68 VSS.t34 106.365
R112 VSS.n84 VSS.t36 106.365
R113 VSS.n93 VSS.t42 106.365
R114 VSS.t48 VSS.t5 94.546
R115 VSS.t45 VSS.t7 94.546
R116 VSS.t46 VSS.t6 94.546
R117 VSS.t51 VSS.t4 94.546
R118 VSS.t49 VSS.t1 70.9096
R119 VSS.t44 VSS.t18 70.9096
R120 VSS.t47 VSS.t10 70.9096
R121 VSS.t50 VSS.t16 70.9096
R122 VSS.n62 VSS.t5 59.0914
R123 VSS.t7 VSS.n44 59.0914
R124 VSS.n87 VSS.t6 59.0914
R125 VSS.t4 VSS.n27 59.0914
R126 VSS.n150 VSS.n2 52.5005
R127 VSS.n49 VSS.n2 52.5005
R128 VSS.n58 VSS.n49 52.5005
R129 VSS.n58 VSS.n45 52.5005
R130 VSS.n53 VSS.n45 52.5005
R131 VSS.n53 VSS.n43 52.5005
R132 VSS.n50 VSS.n43 52.5005
R133 VSS.n50 VSS.n38 52.5005
R134 VSS.n79 VSS.n38 52.5005
R135 VSS.n79 VSS.n32 52.5005
R136 VSS.n83 VSS.n32 52.5005
R137 VSS.n83 VSS.n28 52.5005
R138 VSS.n34 VSS.n28 52.5005
R139 VSS.n34 VSS.n26 52.5005
R140 VSS.n26 VSS.n16 52.5005
R141 VSS.n135 VSS.n134 52.5005
R142 VSS.n139 VSS.n138 52.5005
R143 VSS.n143 VSS.n142 52.5005
R144 VSS.n147 VSS.n10 52.5005
R145 VSS.n48 VSS.n5 52.5005
R146 VSS.n63 VSS.n48 52.5005
R147 VSS.n63 VSS.n46 52.5005
R148 VSS.n67 VSS.n46 52.5005
R149 VSS.n67 VSS.n42 52.5005
R150 VSS.n72 VSS.n42 52.5005
R151 VSS.n72 VSS.n40 52.5005
R152 VSS.n76 VSS.n40 52.5005
R153 VSS.n76 VSS.n31 52.5005
R154 VSS.n88 VSS.n31 52.5005
R155 VSS.n88 VSS.n29 52.5005
R156 VSS.n92 VSS.n29 52.5005
R157 VSS.n92 VSS.n25 52.5005
R158 VSS.n97 VSS.n25 52.5005
R159 VSS.n97 VSS.n23 52.5005
R160 VSS.n100 VSS.n17 52.5005
R161 VSS.n104 VSS.n103 52.5005
R162 VSS.n106 VSS.n21 52.5005
R163 VSS.n22 VSS.n21 52.5005
R164 VSS.n150 VSS.n3 50.7505
R165 VSS.n115 VSS.n16 50.7505
R166 VSS.t14 VSS.t13 47.2732
R167 VSS.t1 VSS.t2 47.2732
R168 VSS.t30 VSS.t32 47.2732
R169 VSS.t32 VSS.t28 47.2732
R170 VSS.t28 VSS.t34 47.2732
R171 VSS.t18 VSS.t12 47.2732
R172 VSS.t9 VSS.t8 47.2732
R173 VSS.t20 VSS.t22 47.2732
R174 VSS.t26 VSS.t24 47.2732
R175 VSS.t17 VSS.t3 47.2732
R176 VSS.t10 VSS.t11 47.2732
R177 VSS.t36 VSS.t38 47.2732
R178 VSS.t38 VSS.t40 47.2732
R179 VSS.t40 VSS.t42 47.2732
R180 VSS.t16 VSS.t15 47.2732
R181 VSS.t19 VSS.t0 47.2732
R182 VSS.n62 VSS.n61 46.0914
R183 VSS.n70 VSS.n44 46.0914
R184 VSS.n87 VSS.n86 46.0914
R185 VSS.n95 VSS.n27 46.0914
R186 VSS.n147 VSS.n5 42.0005
R187 VSS.n111 VSS.n23 42.0005
R188 VSS.n60 VSS.t49 36.6369
R189 VSS.n69 VSS.t44 36.6369
R190 VSS.n85 VSS.t47 36.6369
R191 VSS.n94 VSS.t50 36.6369
R192 VSS.t2 VSS.n59 35.455
R193 VSS.t12 VSS.n68 35.455
R194 VSS.n71 VSS.t20 35.455
R195 VSS.n78 VSS.t26 35.455
R196 VSS.t11 VSS.n84 35.455
R197 VSS.t15 VSS.n93 35.455
R198 VSS VSS.n152 19.0449
R199 VSS.n132 VSS.n131 11.2705
R200 VSS.n118 VSS.n117 11.2705
R201 VSS.n125 VSS.n12 11.1282
R202 VSS.n124 VSS.n13 11.1282
R203 VSS.n60 VSS.t48 10.6369
R204 VSS.n69 VSS.t45 10.6369
R205 VSS.n85 VSS.t46 10.6369
R206 VSS.n94 VSS.t51 10.6369
R207 VSS.n120 VSS.n119 6.29333
R208 VSS.n122 VSS.n121 6.29333
R209 VSS.n128 VSS.n127 6.29333
R210 VSS.n130 VSS.n129 6.29333
R211 VSS.n148 VSS.n147 5.2005
R212 VSS.n147 VSS.n146 5.2005
R213 VSS.n145 VSS.n10 5.2005
R214 VSS.n144 VSS.n143 5.2005
R215 VSS.n142 VSS.n141 5.2005
R216 VSS.n140 VSS.n139 5.2005
R217 VSS.n138 VSS.n137 5.2005
R218 VSS.n136 VSS.n135 5.2005
R219 VSS.n134 VSS.n133 5.2005
R220 VSS.n3 VSS.n0 5.2005
R221 VSS.n149 VSS.n5 5.2005
R222 VSS.n11 VSS.n5 5.2005
R223 VSS.n48 VSS.n4 5.2005
R224 VSS.n48 VSS.n47 5.2005
R225 VSS.n63 VSS.n62 5.2005
R226 VSS.n64 VSS.n63 5.2005
R227 VSS.n59 VSS.n46 5.2005
R228 VSS.n65 VSS.n46 5.2005
R229 VSS.n68 VSS.n67 5.2005
R230 VSS.n67 VSS.n66 5.2005
R231 VSS.n44 VSS.n42 5.2005
R232 VSS.n42 VSS.n41 5.2005
R233 VSS.n72 VSS.n71 5.2005
R234 VSS.n73 VSS.n72 5.2005
R235 VSS.n40 VSS.n39 5.2005
R236 VSS.n74 VSS.n40 5.2005
R237 VSS.n77 VSS.n76 5.2005
R238 VSS.n76 VSS.n75 5.2005
R239 VSS.n78 VSS.n31 5.2005
R240 VSS.n31 VSS.n30 5.2005
R241 VSS.n88 VSS.n87 5.2005
R242 VSS.n89 VSS.n88 5.2005
R243 VSS.n84 VSS.n29 5.2005
R244 VSS.n90 VSS.n29 5.2005
R245 VSS.n93 VSS.n92 5.2005
R246 VSS.n92 VSS.n91 5.2005
R247 VSS.n27 VSS.n25 5.2005
R248 VSS.n25 VSS.n24 5.2005
R249 VSS.n97 VSS.n96 5.2005
R250 VSS.n98 VSS.n97 5.2005
R251 VSS.n23 VSS.n20 5.2005
R252 VSS.n99 VSS.n23 5.2005
R253 VSS.n116 VSS.n115 5.2005
R254 VSS.n17 VSS.n14 5.2005
R255 VSS.n101 VSS.n100 5.2005
R256 VSS.n103 VSS.n102 5.2005
R257 VSS.n105 VSS.n104 5.2005
R258 VSS.n107 VSS.n106 5.2005
R259 VSS.n113 VSS.n21 5.2005
R260 VSS.n108 VSS.n21 5.2005
R261 VSS.n109 VSS.n22 5.2005
R262 VSS.n111 VSS.n110 5.2005
R263 VSS.n20 VSS.n16 5.2005
R264 VSS.n16 VSS.n15 5.2005
R265 VSS.n96 VSS.n26 5.2005
R266 VSS.n33 VSS.n26 5.2005
R267 VSS.n34 VSS.n27 5.2005
R268 VSS.n35 VSS.n34 5.2005
R269 VSS.n93 VSS.n28 5.2005
R270 VSS.n36 VSS.n28 5.2005
R271 VSS.n84 VSS.n83 5.2005
R272 VSS.n83 VSS.n82 5.2005
R273 VSS.n87 VSS.n32 5.2005
R274 VSS.n81 VSS.n32 5.2005
R275 VSS.n79 VSS.n78 5.2005
R276 VSS.n80 VSS.n79 5.2005
R277 VSS.n77 VSS.n38 5.2005
R278 VSS.n38 VSS.n37 5.2005
R279 VSS.n50 VSS.n39 5.2005
R280 VSS.n51 VSS.n50 5.2005
R281 VSS.n71 VSS.n43 5.2005
R282 VSS.n52 VSS.n43 5.2005
R283 VSS.n53 VSS.n44 5.2005
R284 VSS.n54 VSS.n53 5.2005
R285 VSS.n68 VSS.n45 5.2005
R286 VSS.n55 VSS.n45 5.2005
R287 VSS.n59 VSS.n58 5.2005
R288 VSS.n58 VSS.n57 5.2005
R289 VSS.n62 VSS.n49 5.2005
R290 VSS.n56 VSS.n49 5.2005
R291 VSS.n4 VSS.n2 5.2005
R292 VSS.n2 VSS.n1 5.2005
R293 VSS.n150 VSS.n149 5.2005
R294 VSS.n151 VSS.n150 5.2005
R295 VSS.n131 VSS.n130 4.5005
R296 VSS.n128 VSS.n126 4.5005
R297 VSS.n123 VSS.n122 4.5005
R298 VSS.n120 VSS.n118 4.5005
R299 VSS.n10 VSS.n9 4.34122
R300 VSS.n142 VSS.n8 4.34122
R301 VSS.n138 VSS.n7 4.34122
R302 VSS.n134 VSS.n6 4.34122
R303 VSS.n115 VSS.n114 4.34122
R304 VSS.n100 VSS.n19 4.34122
R305 VSS.n104 VSS.n18 4.34122
R306 VSS.n112 VSS.n22 4.34122
R307 VSS.n6 VSS.n3 4.34122
R308 VSS.n135 VSS.n7 4.34122
R309 VSS.n139 VSS.n8 4.34122
R310 VSS.n143 VSS.n9 4.34122
R311 VSS.n114 VSS.n17 4.34122
R312 VSS.n103 VSS.n19 4.34122
R313 VSS.n106 VSS.n18 4.34122
R314 VSS.n112 VSS.n111 4.34122
R315 VSS.n95 VSS.n94 3.58947
R316 VSS.n86 VSS.n85 3.58947
R317 VSS.n70 VSS.n69 3.58947
R318 VSS.n61 VSS.n60 3.58947
R319 VSS.n125 VSS.n124 1.6005
R320 VSS.n126 VSS.n125 1.5205
R321 VSS.n124 VSS.n123 1.5205
R322 VSS.n12 VSS.t21 0.8195
R323 VSS.n12 VSS.t23 0.8195
R324 VSS.n13 VSS.t25 0.8195
R325 VSS.n13 VSS.t27 0.8195
R326 VSS.n136 VSS.n133 0.6755
R327 VSS.n137 VSS.n136 0.6755
R328 VSS.n140 VSS.n137 0.6755
R329 VSS.n141 VSS.n140 0.6755
R330 VSS.n144 VSS.n141 0.6755
R331 VSS.n145 VSS.n144 0.6755
R332 VSS.n146 VSS.n145 0.6755
R333 VSS.n47 VSS.n11 0.6755
R334 VSS.n64 VSS.n47 0.6755
R335 VSS.n65 VSS.n64 0.6755
R336 VSS.n66 VSS.n65 0.6755
R337 VSS.n66 VSS.n41 0.6755
R338 VSS.n73 VSS.n41 0.6755
R339 VSS.n74 VSS.n73 0.6755
R340 VSS.n75 VSS.n74 0.6755
R341 VSS.n75 VSS.n30 0.6755
R342 VSS.n89 VSS.n30 0.6755
R343 VSS.n90 VSS.n89 0.6755
R344 VSS.n91 VSS.n90 0.6755
R345 VSS.n91 VSS.n24 0.6755
R346 VSS.n98 VSS.n24 0.6755
R347 VSS.n99 VSS.n98 0.6755
R348 VSS.n101 VSS.n14 0.6755
R349 VSS.n102 VSS.n101 0.6755
R350 VSS.n105 VSS.n102 0.6755
R351 VSS.n107 VSS.n105 0.6755
R352 VSS.n108 VSS.n107 0.6755
R353 VSS.n109 VSS.n108 0.6755
R354 VSS.n110 VSS.n109 0.6755
R355 VSS.n151 VSS.n1 0.6755
R356 VSS.n56 VSS.n1 0.6755
R357 VSS.n57 VSS.n56 0.6755
R358 VSS.n57 VSS.n55 0.6755
R359 VSS.n55 VSS.n54 0.6755
R360 VSS.n54 VSS.n52 0.6755
R361 VSS.n52 VSS.n51 0.6755
R362 VSS.n51 VSS.n37 0.6755
R363 VSS.n80 VSS.n37 0.6755
R364 VSS.n81 VSS.n80 0.6755
R365 VSS.n82 VSS.n81 0.6755
R366 VSS.n82 VSS.n36 0.6755
R367 VSS.n36 VSS.n35 0.6755
R368 VSS.n35 VSS.n33 0.6755
R369 VSS.n33 VSS.n15 0.6755
R370 VSS.n116 VSS.n15 0.653
R371 VSS.n133 VSS.n132 0.563
R372 VSS.n117 VSS.n14 0.563
R373 VSS.n146 VSS.n11 0.5405
R374 VSS.n110 VSS.n99 0.5405
R375 VSS.n148 VSS.n9 0.430889
R376 VSS.n148 VSS.n8 0.430889
R377 VSS.n148 VSS.n7 0.430889
R378 VSS.n148 VSS.n6 0.430889
R379 VSS.n114 VSS.n113 0.430889
R380 VSS.n113 VSS.n19 0.430889
R381 VSS.n113 VSS.n18 0.430889
R382 VSS.n113 VSS.n112 0.430889
R383 VSS.n152 VSS.n151 0.37175
R384 VSS.n152 VSS.n0 0.28175
R385 VSS.n122 VSS.n120 0.189974
R386 VSS.n130 VSS.n128 0.189974
R387 VSS.n119 VSS.t41 0.1643
R388 VSS.n119 VSS.t43 0.1643
R389 VSS.n121 VSS.t37 0.1643
R390 VSS.n121 VSS.t39 0.1643
R391 VSS.n127 VSS.t29 0.1643
R392 VSS.n127 VSS.t35 0.1643
R393 VSS.n129 VSS.t31 0.1643
R394 VSS.n129 VSS.t33 0.1643
R395 VSS.n131 VSS.n126 0.1605
R396 VSS.n123 VSS.n118 0.1605
R397 VSS.n132 VSS.n0 0.113
R398 VSS.n117 VSS.n116 0.113
R399 a_3548_n2400.n5 a_3548_n2400.n3 10.7791
R400 a_3548_n2400.n5 a_3548_n2400.n4 10.7791
R401 a_3548_n2400.t3 a_3548_n2400.n7 6.55182
R402 a_3548_n2400.n2 a_3548_n2400.t0 6.45713
R403 a_3548_n2400.n1 a_3548_n2400.n0 6.29333
R404 a_3548_n2400.n6 a_3548_n2400.n2 4.63668
R405 a_3548_n2400.n7 a_3548_n2400.n6 2.23814
R406 a_3548_n2400.n6 a_3548_n2400.n5 0.3305
R407 a_3548_n2400.n3 a_3548_n2400.t6 0.20525
R408 a_3548_n2400.n3 a_3548_n2400.t7 0.20525
R409 a_3548_n2400.n4 a_3548_n2400.t4 0.20525
R410 a_3548_n2400.n4 a_3548_n2400.t5 0.20525
R411 a_3548_n2400.n2 a_3548_n2400.n1 0.189974
R412 a_3548_n2400.n0 a_3548_n2400.t1 0.1643
R413 a_3548_n2400.n0 a_3548_n2400.t2 0.1643
R414 a_3548_n2400.n7 a_3548_n2400.n1 0.0924286
R415 a_n6052_n2400.n5 a_n6052_n2400.n3 10.7791
R416 a_n6052_n2400.n5 a_n6052_n2400.n4 10.7791
R417 a_n6052_n2400.t3 a_n6052_n2400.n7 6.55182
R418 a_n6052_n2400.n2 a_n6052_n2400.t0 6.45713
R419 a_n6052_n2400.n1 a_n6052_n2400.n0 6.29333
R420 a_n6052_n2400.n6 a_n6052_n2400.n2 4.63668
R421 a_n6052_n2400.n7 a_n6052_n2400.n6 2.23814
R422 a_n6052_n2400.n6 a_n6052_n2400.n5 0.3305
R423 a_n6052_n2400.n3 a_n6052_n2400.t5 0.20525
R424 a_n6052_n2400.n3 a_n6052_n2400.t4 0.20525
R425 a_n6052_n2400.n4 a_n6052_n2400.t6 0.20525
R426 a_n6052_n2400.n4 a_n6052_n2400.t7 0.20525
R427 a_n6052_n2400.n2 a_n6052_n2400.n1 0.189974
R428 a_n6052_n2400.n0 a_n6052_n2400.t1 0.1643
R429 a_n6052_n2400.n0 a_n6052_n2400.t2 0.1643
R430 a_n6052_n2400.n7 a_n6052_n2400.n1 0.0924286
R431 a_3948_200.n2 a_3948_200.n0 15.3662
R432 a_3948_200.n2 a_3948_200.n1 14.5662
R433 a_3948_200.n3 a_3948_200.n2 7.70696
R434 a_3948_200.n3 a_3948_200.t5 5.9772
R435 a_3948_200.t4 a_3948_200.n3 5.9772
R436 a_3948_200.n0 a_3948_200.t1 0.2735
R437 a_3948_200.n0 a_3948_200.t0 0.2735
R438 a_3948_200.n1 a_3948_200.t3 0.2735
R439 a_3948_200.n1 a_3948_200.t2 0.2735
R440 a_2348_200.n2 a_2348_200.n0 19.8662
R441 a_2348_200.n2 a_2348_200.n1 19.3329
R442 a_2348_200.n3 a_2348_200.n2 11.5875
R443 a_2348_200.n3 a_2348_200.t5 5.9772
R444 a_2348_200.t4 a_2348_200.n3 5.9772
R445 a_2348_200.n1 a_2348_200.t1 0.2735
R446 a_2348_200.n1 a_2348_200.t2 0.2735
R447 a_2348_200.n0 a_2348_200.t3 0.2735
R448 a_2348_200.n0 a_2348_200.t0 0.2735
R449 a_n5652_200.n2 a_n5652_200.n0 15.3662
R450 a_n5652_200.n2 a_n5652_200.n1 14.5662
R451 a_n5652_200.n3 a_n5652_200.n2 7.70696
R452 a_n5652_200.n3 a_n5652_200.t5 5.9772
R453 a_n5652_200.t4 a_n5652_200.n3 5.9772
R454 a_n5652_200.n0 a_n5652_200.t1 0.2735
R455 a_n5652_200.n0 a_n5652_200.t0 0.2735
R456 a_n5652_200.n1 a_n5652_200.t3 0.2735
R457 a_n5652_200.n1 a_n5652_200.t2 0.2735
R458 a_n7252_200.n2 a_n7252_200.n0 19.8662
R459 a_n7252_200.n2 a_n7252_200.n1 19.3329
R460 a_n7252_200.n3 a_n7252_200.n2 11.5875
R461 a_n7252_200.n3 a_n7252_200.t5 5.9772
R462 a_n7252_200.t4 a_n7252_200.n3 5.9772
R463 a_n7252_200.n1 a_n7252_200.t2 0.2735
R464 a_n7252_200.n1 a_n7252_200.t3 0.2735
R465 a_n7252_200.n0 a_n7252_200.t1 0.2735
R466 a_n7252_200.n0 a_n7252_200.t0 0.2735
R467 a_n5720_0.n1 a_n5720_0.t9 87.5461
R468 a_n5720_0.n1 a_n5720_0.t10 87.5461
R469 a_n5720_0.n8 a_n5720_0.t7 87.5461
R470 a_n5720_0.n8 a_n5720_0.t8 87.5461
R471 a_n5720_0.n9 a_n5720_0.n8 36.4819
R472 a_n5720_0.n2 a_n5720_0.n1 26.3484
R473 a_n5720_0.n9 a_n5720_0.t0 13.21
R474 a_n5720_0.n0 a_n5720_0.t6 7.21035
R475 a_n5720_0.n0 a_n5720_0.t5 7.20745
R476 a_n5720_0.t2 a_n5720_0.n10 5.96544
R477 a_n5720_0.n10 a_n5720_0.t1 5.9622
R478 a_n5720_0.n7 a_n5720_0.n0 5.94824
R479 a_n5720_0.n5 a_n5720_0.t4 5.87051
R480 a_n5720_0.n4 a_n5720_0.t3 5.87051
R481 a_n5720_0.n4 a_n5720_0.n3 4.5005
R482 a_n5720_0.n6 a_n5720_0.n5 4.5005
R483 a_n5720_0.n10 a_n5720_0.n9 2.56391
R484 a_n5720_0.n7 a_n5720_0.n2 0.419
R485 a_n5720_0.n9 a_n5720_0.n7 0.2415
R486 a_n5720_0.n5 a_n5720_0.n4 0.189974
R487 a_n5720_0.n6 a_n5720_0.n3 0.1605
R488 a_n5720_0.n7 a_n5720_0.n6 0.0795
R489 a_n5720_0.n3 a_n5720_0.n2 0.0405
R490 a_n7396_200.n1 a_n7396_200.t7 87.5461
R491 a_n7396_200.n1 a_n7396_200.t8 87.5461
R492 a_n7396_200.n4 a_n7396_200.t5 87.5461
R493 a_n7396_200.n4 a_n7396_200.t6 87.5461
R494 a_n7396_200.n5 a_n7396_200.n4 36.547
R495 a_n7396_200.n2 a_n7396_200.n1 35.155
R496 a_n7396_200.n5 a_n7396_200.t2 13.21
R497 a_n7396_200.n3 a_n7396_200.t3 5.96544
R498 a_n7396_200.n3 a_n7396_200.t4 5.9622
R499 a_n7396_200.t1 a_n7396_200.n9 5.87051
R500 a_n7396_200.n8 a_n7396_200.t0 5.87051
R501 a_n7396_200.n8 a_n7396_200.n7 4.5005
R502 a_n7396_200.n9 a_n7396_200.n0 4.5005
R503 a_n7396_200.n5 a_n7396_200.n3 2.56391
R504 a_n7396_200.n6 a_n7396_200.n2 0.419
R505 a_n7396_200.n6 a_n7396_200.n5 0.2415
R506 a_n7396_200.n9 a_n7396_200.n8 0.189974
R507 a_n7396_200.n7 a_n7396_200.n0 0.1605
R508 a_n7396_200.n7 a_n7396_200.n6 0.0795
R509 a_n7396_200.n2 a_n7396_200.n0 0.0740593
C0 VBIAS CLK_P 0.06295f
C1 CLK_P DIV_P 0.15102f
C2 CLK_N CLK_P 1.88251f
C3 VDD DIV_P 0.0275f
C4 RESET VBIAS 0.24607f
C5 RESET DIV_P 0.17615f
C6 VBIAS DIV_P 0.01093f
C7 DIV_N VDD 0.0275f
C8 RESET CLK_N 0.13985f
C9 CLK_N VBIAS 0.64976f
C10 CLK_N DIV_P 0.56961f
C11 RESET CLK_P 0.61207f
C12 DIV_N DIV_P 1.62269f
C13 RESET VSS 3.73451f
C14 VBIAS VSS 7.43788f
C15 CLK_N VSS 5.5624f
C16 CLK_P VSS 6.4879f
C17 DIV_N VSS 7.83655f
C18 DIV_P VSS 12.53184f
C19 VDD VSS 9.69424f
C20 a_n7396_200.n0 VSS 0.06332f
C21 a_n7396_200.n1 VSS 0.26675f
C22 a_n7396_200.n2 VSS 0.64514f
C23 a_n7396_200.t2 VSS 0.11782f
C24 a_n7396_200.t3 VSS 0.24616f
C25 a_n7396_200.t4 VSS 0.2461f
C26 a_n7396_200.n3 VSS 0.15007f
C27 a_n7396_200.n4 VSS 1.25274f
C28 a_n7396_200.n5 VSS 3.57313f
C29 a_n7396_200.n6 VSS 0.20259f
C30 a_n7396_200.n7 VSS 0.05515f
C31 a_n7396_200.t0 VSS 0.25018f
C32 a_n7396_200.n8 VSS 0.06487f
C33 a_n7396_200.n9 VSS 0.06487f
C34 a_n7396_200.t1 VSS 0.25018f
C35 a_n5720_0.t1 VSS 0.33666f
C36 a_n5720_0.t0 VSS 0.17183f
C37 a_n5720_0.t5 VSS 0.10723f
C38 a_n5720_0.t6 VSS 0.10731f
C39 a_n5720_0.n0 VSS 0.84645f
C40 a_n5720_0.n1 VSS 0.2785f
C41 a_n5720_0.n2 VSS 0.92958f
C42 a_n5720_0.n3 VSS 0.0673f
C43 a_n5720_0.t4 VSS 0.32485f
C44 a_n5720_0.t3 VSS 0.32485f
C45 a_n5720_0.n4 VSS 0.0946f
C46 a_n5720_0.n5 VSS 0.0946f
C47 a_n5720_0.n6 VSS 0.08043f
C48 a_n5720_0.n7 VSS 1.42002f
C49 a_n5720_0.n8 VSS 0.9783f
C50 a_n5720_0.n9 VSS 2.96344f
C51 a_n5720_0.n10 VSS 0.21887f
C52 a_n5720_0.t2 VSS 0.33676f
C53 a_n7252_200.t5 VSS 0.63166f
C54 a_n7252_200.t1 VSS 0.13362f
C55 a_n7252_200.t0 VSS 0.13362f
C56 a_n7252_200.n0 VSS 0.50244f
C57 a_n7252_200.t2 VSS 0.13446f
C58 a_n7252_200.t3 VSS 0.13446f
C59 a_n7252_200.n1 VSS 0.46578f
C60 a_n7252_200.n2 VSS 3.55595f
C61 a_n7252_200.n3 VSS 0.49188f
C62 a_n7252_200.t4 VSS 0.63166f
C63 a_n5652_200.t5 VSS 0.84332f
C64 a_n5652_200.t1 VSS 0.16874f
C65 a_n5652_200.t0 VSS 0.16874f
C66 a_n5652_200.n0 VSS 0.60338f
C67 a_n5652_200.t3 VSS 0.15247f
C68 a_n5652_200.t2 VSS 0.15247f
C69 a_n5652_200.n1 VSS 0.56653f
C70 a_n5652_200.n2 VSS 2.70161f
C71 a_n5652_200.n3 VSS 0.66423f
C72 a_n5652_200.t4 VSS 0.84332f
C73 a_2348_200.t5 VSS 0.6555f
C74 a_2348_200.t3 VSS 0.12422f
C75 a_2348_200.t0 VSS 0.12422f
C76 a_2348_200.n0 VSS 0.50792f
C77 a_2348_200.t1 VSS 0.1405f
C78 a_2348_200.t2 VSS 0.1405f
C79 a_2348_200.n1 VSS 0.47086f
C80 a_2348_200.n2 VSS 3.59473f
C81 a_2348_200.n3 VSS 0.49724f
C82 a_2348_200.t4 VSS 0.6555f
C83 a_3948_200.t5 VSS 0.82685f
C84 a_3948_200.t1 VSS 0.16297f
C85 a_3948_200.t0 VSS 0.16297f
C86 a_3948_200.n0 VSS 0.60416f
C87 a_3948_200.t3 VSS 0.16381f
C88 a_3948_200.t2 VSS 0.16381f
C89 a_3948_200.n1 VSS 0.56726f
C90 a_3948_200.n2 VSS 2.7051f
C91 a_3948_200.n3 VSS 0.66508f
C92 a_3948_200.t4 VSS 0.82685f
C93 a_n6052_n2400.t2 VSS 0.13857f
C94 a_n6052_n2400.t1 VSS 0.13857f
C95 a_n6052_n2400.n0 VSS 0.40722f
C96 a_n6052_n2400.n1 VSS 0.13267f
C97 a_n6052_n2400.t0 VSS 0.5774f
C98 a_n6052_n2400.n2 VSS 0.11869f
C99 a_n6052_n2400.t4 VSS 0.15416f
C100 a_n6052_n2400.t5 VSS 0.15416f
C101 a_n6052_n2400.n3 VSS 0.37895f
C102 a_n6052_n2400.t7 VSS 0.13668f
C103 a_n6052_n2400.t6 VSS 0.13668f
C104 a_n6052_n2400.n4 VSS 0.37895f
C105 a_n6052_n2400.n5 VSS 1.16222f
C106 a_n6052_n2400.n6 VSS 0.35035f
C107 a_n6052_n2400.n7 VSS 0.11697f
C108 a_n6052_n2400.t3 VSS 0.57912f
C109 a_3548_n2400.t2 VSS 0.13536f
C110 a_3548_n2400.t1 VSS 0.13536f
C111 a_3548_n2400.n0 VSS 0.39544f
C112 a_3548_n2400.n1 VSS 0.12883f
C113 a_3548_n2400.t0 VSS 0.56152f
C114 a_3548_n2400.n2 VSS 0.11525f
C115 a_3548_n2400.t7 VSS 0.13411f
C116 a_3548_n2400.t6 VSS 0.13411f
C117 a_3548_n2400.n3 VSS 0.36799f
C118 a_3548_n2400.t5 VSS 0.15159f
C119 a_3548_n2400.t4 VSS 0.15159f
C120 a_3548_n2400.n4 VSS 0.36799f
C121 a_3548_n2400.n5 VSS 1.12862f
C122 a_3548_n2400.n6 VSS 0.34022f
C123 a_3548_n2400.n7 VSS 0.11359f
C124 a_3548_n2400.t3 VSS 0.56318f
C125 VSS.t23 VSS 0.01221f
C126 VSS.t21 VSS 0.01219f
C127 VSS.t27 VSS 0.01219f
C128 VSS.t25 VSS 0.01221f
C129 VSS.t43 VSS 0.02815f
C130 VSS.t41 VSS 0.02775f
C131 VSS.t39 VSS 0.02775f
C132 VSS.t37 VSS 0.02815f
C133 VSS.t35 VSS 0.02815f
C134 VSS.t29 VSS 0.02775f
C135 VSS.t33 VSS 0.02775f
C136 VSS.t31 VSS 0.02815f
C137 VDD.n0 VSS 0.0401f
C138 VDD.n1 VSS 0.0391f
C139 DIV_P.t1 VSS 0.12787f
C140 DIV_P.n0 VSS 0.3273f
C141 DIV_P.n1 VSS 0.91083f
C142 DIV_P.t6 VSS 0.0979f
C143 DIV_P.t5 VSS 0.09798f
C144 DIV_P.n2 VSS 0.76336f
C145 DIV_P.n3 VSS 0.0607f
C146 DIV_P.t2 VSS 0.30681f
C147 DIV_P.n4 VSS 0.08531f
C148 DIV_P.t3 VSS 0.30681f
C149 DIV_P.n5 VSS 0.08531f
C150 DIV_P.n6 VSS 0.07253f
C151 DIV_P.n7 VSS 1.28062f
C152 DIV_P.n8 VSS 1.43711f
C153 DIV_P.t4 VSS 0.31412f
C154 DIV_P.t0 VSS 0.31404f
C155 DIV_P.n9 VSS 0.19739f
C156 DIV_P.n10 VSS 3.49974f
C157 DIV_N.t2 VSS 0.12558f
C158 DIV_N.t0 VSS 0.29306f
C159 DIV_N.t4 VSS 0.29314f
C160 DIV_N.n0 VSS 0.19384f
C161 DIV_N.n1 VSS 0.8936f
C162 DIV_N.n2 VSS 0.26159f
C163 DIV_N.n3 VSS 0.77027f
C164 DIV_N.n4 VSS 0.08179f
C165 DIV_N.t1 VSS 0.30296f
C166 DIV_N.t3 VSS 0.30296f
C167 DIV_N.n5 VSS 0.08378f
C168 DIV_N.n6 VSS 0.08378f
C169 DIV_N.n7 VSS 0.07123f
C170 DIV_N.n8 VSS 0.26168f
C171 DIV_N.n9 VSS 2.67008f
C172 CLK_P.n0 VSS 0.16951f
C173 CLK_P.n1 VSS 0.32575f
C174 CLK_P.n2 VSS 3.01588f
C175 CLK_N.n0 VSS 0.21038f
C176 CLK_N.n1 VSS 0.42756f
C177 CLK_N.n2 VSS 3.09592f
C178 VBIAS.n0 VSS 0.02485f
C179 VBIAS.n1 VSS 0.02665f
C180 VBIAS.n2 VSS 0.02665f
C181 VBIAS.n3 VSS 0.02485f
C182 VBIAS.n4 VSS 0.21917f
C183 VBIAS.n5 VSS 0.02485f
C184 VBIAS.n6 VSS 0.02665f
C185 VBIAS.n7 VSS 0.02665f
C186 VBIAS.n8 VSS 0.02485f
C187 VBIAS.n9 VSS 0.07559f
C188 VBIAS.n10 VSS 0.92431f
C189 VBIAS.n11 VSS 0.11855f
C190 RESET.n0 VSS 0.13406f
C191 RESET.n1 VSS 0.13406f
C192 RESET.n2 VSS 0.90369f
.ends
