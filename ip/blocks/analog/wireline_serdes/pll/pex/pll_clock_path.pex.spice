* PEX produced on Thu Aug 20 01:18:51 AM CEST 2026 using /foss/tools/sak/sak-pex.sh with m=3 and s=1 (extresist threshold=0 mOhm, minres=1 mOhm, mindelay=0 ps)
* NGSPICE file created from pll_clock_path_pex.ext - technology: gf180mcuD

.subckt pll_clock_path_pex VREFH VREFL VDD VSS F_A4 F_A4B F_A3 F_A3B F_A2 F_A2B F_A1
+ F_A1B F_A0 F_A0B F_B4 F_B4B F_B3 F_B3B F_B2 F_B2B F_B1 F_B1B F_B0 F_B0B G_A4 G_A4B
+ G_A3 G_A3B G_A2 G_A2B G_A1 G_A1B G_A0 G_A0B G_B4 G_B4B G_B3 G_B3B G_B2 G_B2B G_B1
+ G_B1B G_B0 G_B0B FAST_KICKP FAST_KICKN GAIN_KICKP GAIN_KICKN SEL_A SEL_B SEL_BUF
+ REST_BIAS DIV_RESET DIV_BIAS DIV_P DIV_N
X0 VREFH.t10 G_A0.t1 a_24600_n37702.t0 VSS.t154 nfet_03v3 ad=2.08p pd=8.52u as=3.52p ps=16.88u w=8u l=0.28u
X1 VSS.t12 REST_BIAS.t7 a_2148_76800.t0 VSS.t10 nfet_03v3 ad=3.12p pd=12.52u as=5.28p ps=24.88u w=12u l=0.28u
X2 a_n5852_53500.t6 XBANK.XSEL.A_P.t7 a_n5996_53500.t6 VSS.t164 nfet_03v3 ad=1.3p pd=5.52u as=2.2p ps=10.88u w=5u l=0.28u
X3 a_4628_86600.t0 XREST.OUT_N.t6 a_5028_89200.t1 VSS.t40 nfet_03v3 ad=2.08p pd=8.52u as=3.52p ps=16.88u w=8u l=0.28u
X4 VREFL.t24 F_A0B.t1 a_n31400_n37702.t1 VSS.t226 nfet_03v3 ad=2.08p pd=8.52u as=3.52p ps=16.88u w=8u l=0.28u
X5 a_n31052_25100.t0 XBANK.XFAST.X2.INN.t7 XBANK.XFAST.XBUF.INN.t2 VSS.t22 nfet_03v3 ad=1.3p pd=5.52u as=2.2p ps=10.88u w=5u l=0.28u
X6 a_n28972_25200.t1 XBANK.XFDAC.CTRL_B VSS.t78 VSS.t76 nfet_03v3 ad=2.64p pd=12.88u as=1.56p ps=6.52u w=6u l=0.28u
X7 XBANK.XGAIN.XBUF.INP.t3 XBANK.XGAIN.X2.INP.t6 a_24948_25100.t7 VSS.t59 nfet_03v3 ad=2.2p pd=10.88u as=1.3p ps=5.52u w=5u l=0.28u
X8 VSS.t188 XBANK.XGAIN.XSTART.NODEP.t6 VSS.t187 VSS.t66 nfet_03v3 ad=1.76p pd=8.88u as=0 ps=0 w=4u l=3.45u
X9 XBANK.XFDAC.CTRL_A a_n41900_n28902# VSS.t239 ppolyf_u r_width=2u r_length=20u
X10 a_4628_86600.t7 DIV_BIAS.t4 VSS.t127 VSS.t126 nfet_03v3 ad=4.4p pd=20.88u as=2.6p ps=10.52u w=10u l=0.28u
X11 VSS.t129 DIV_BIAS.t1 a_14228_86600.t4 VSS.t128 nfet_03v3 ad=2.6p pd=10.52u as=2.6p ps=10.52u w=10u l=0.28u
X12 a_27028_38000.t1 XBANK.XSEL.B_P.t4 XBANK.XSEL.B_N.t0 VSS.t94 nfet_03v3 ad=1.76p pd=8.88u as=1.76p ps=8.88u w=4u l=0.28u
X13 VREFL.t8 G_B1B.t1 a_34000_n37702.t0 VSS.t98 nfet_03v3 ad=2.08p pd=8.52u as=3.52p ps=16.88u w=8u l=0.28u
X14 a_n34400_n37702.t1 F_A1.t0 VREFH.t27 VSS.t34 nfet_03v3 ad=3.52p pd=16.88u as=2.08p ps=8.52u w=8u l=0.28u
X15 VDD.t6 XBANK.XGAIN.XSTART.NODEP.t1 VSS.t66 ppolyf_u r_width=2u r_length=6.5u
X16 XBANK.XGDAC.CTRL_B a_38500_n24800# VSS.t254 ppolyf_u r_width=2u r_length=20u
X17 a_27028_12400.t1 XBANK.XGDAC.CTRL_B VSS.t173 VSS.t168 nfet_03v3 ad=1.76p pd=8.88u as=1.04p ps=4.52u w=4u l=0.28u
X18 VREFL.t23 F_B2B.t1 a_n19000_n37702.t2 VSS.t156 nfet_03v3 ad=2.08p pd=8.52u as=3.52p ps=16.88u w=8u l=0.28u
X19 a_n5996_53500.t1 XBANK.XSEL.B_P.t8 a_n4252_53500.t9 VSS.t88 nfet_03v3 ad=2.2p pd=10.88u as=1.3p ps=5.52u w=5u l=0.28u
X20 a_n2796_53500.t3 XBANK.XSEL.A_N.t6 a_n5852_53500.t2 VSS.t24 nfet_03v3 ad=2.2p pd=10.88u as=1.3p ps=5.52u w=5u l=0.28u
X21 VSS.t141 XBANK.XGDAC.CTRL_A a_24948_25100.t4 VSS.t133 nfet_03v3 ad=2.6p pd=10.52u as=2.6p ps=10.52u w=10u l=0.28u
X22 VREFL.t37 F_A4B.t1 a_n43400_n37702.t3 VSS.t100 nfet_03v3 ad=2.08p pd=8.52u as=3.52p ps=16.88u w=8u l=0.28u
X23 DIV_N.t3 a_3284_89200.t5 a_13028_89200.t1 VSS.t84 nfet_03v3 ad=2.64p pd=12.88u as=1.56p ps=6.52u w=6u l=0.28u
X24 XREST.IN_N.t4 a_n2796_53500.t9 a_1748_53500.t9 VSS.t245 nfet_03v3 ad=2.2p pd=10.88u as=1.3p ps=5.52u w=5u l=0.28u
X25 VSS.t232 SEL_BUF.t1 a_1748_53500.t6 VSS.t15 nfet_03v3 ad=2.6p pd=10.52u as=2.6p ps=10.52u w=10u l=0.28u
X26 VSS.t180 DIV_RESET.t1 DIV_P.t3 VSS.t179 nfet_03v3 ad=0.52p pd=2.52u as=0.88p ps=4.88u w=2u l=0.28u
X27 a_2148_76800.t5 a_3600_70348.t4 XREST.OUT_N.t1 VSS.t38 nfet_03v3 ad=2.6p pd=10.52u as=4.4p ps=20.88u w=10u l=0.28u
X28 a_27028_38000.t0 XBANK.XSEL.B_N.t4 XBANK.XSEL.B_P.t3 VSS.t25 nfet_03v3 ad=1.76p pd=8.88u as=1.76p ps=8.88u w=4u l=0.28u
X29 a_27028_n400.t0 XBANK.XGAIN.XSTART.NODEP.t5 XBANK.XGAIN.XSTART.NODEN.t0 VSS.t94 nfet_03v3 ad=1.76p pd=8.88u as=1.76p ps=8.88u w=4u l=0.28u
X30 a_34000_n37702.t4 G_B1.t0 VREFH.t29 VSS.t99 nfet_03v3 ad=3.52p pd=16.88u as=2.08p ps=8.52u w=8u l=0.28u
X31 VDD.t12 XBANK.XSEL.B_P.t2 VSS.t66 ppolyf_u r_width=2u r_length=6.5u
X32 a_24948_n500.t2 XBANK.XGDAC.CTRL_A VSS.t136 VSS.t135 nfet_03v3 ad=2.6p pd=10.52u as=2.6p ps=10.52u w=10u l=0.28u
X33 VDD.t18 DIV_N.t4 VSS.t225 ppolyf_u r_width=2u r_length=7.5u
X34 a_2148_67400.t5 XREST.IN_N.t6 a_3600_70348.t1 VSS.t38 nfet_03v3 ad=2.6p pd=10.52u as=4.4p ps=20.88u w=10u l=0.28u
X35 a_n5852_53500.t5 XBANK.XSEL.A_N.t9 a_n2796_53500.t0 VSS.t161 nfet_03v3 ad=1.3p pd=5.52u as=2.2p ps=10.88u w=5u l=0.28u
X36 VDD.t14 XBANK.XSEL.A_P.t1 VSS.t53 ppolyf_u r_width=2u r_length=4u
X37 VSS.t20 REST_BIAS.t1 a_2148_67400.t2 VSS.t15 nfet_03v3 ad=3.12p pd=12.52u as=3.12p ps=12.52u w=12u l=0.28u
X38 a_n31052_12300.t7 XBANK.XFDAC.CTRL_A VSS.t296 VSS.t287 nfet_03v3 ad=6.6p pd=30.88u as=3.9p ps=15.52u w=15u l=0.28u
X39 a_1748_53500.t3 a_n2796_53500.t12 XREST.IN_N.t1 VSS.t163 nfet_03v3 ad=1.3p pd=5.52u as=2.2p ps=10.88u w=5u l=0.28u
X40 VSS.t73 XBANK.XFDAC.CTRL_B a_n28972_n400.t0 VSS.t71 nfet_03v3 ad=1.56p pd=6.52u as=2.64p ps=12.88u w=6u l=0.28u
X41 VDD.t23 a_n5996_53500.t8 VSS.t268 ppolyf_u r_width=2u r_length=4u
X42 VSS.t28 XBANK.XSEL.B_N.t5 VSS.t27 VSS.t26 nfet_03v3 ad=1.76p pd=8.88u as=0 ps=0 w=4u l=3.45u
X43 a_24948_n500.t7 XBANK.XGAIN.XBUF.INN.t5 XBANK.XGAIN.XSTART.NODEN.t3 VSS.t93 nfet_03v3 ad=1.3p pd=5.52u as=2.2p ps=10.88u w=5u l=0.28u
X44 a_n16000_n37702.t1 F_B3B.t0 VREFL.t34 VSS.t259 nfet_03v3 ad=3.52p pd=16.88u as=2.08p ps=8.52u w=8u l=0.28u
X45 VSS.t16 REST_BIAS.t5 a_2148_76800.t2 VSS.t15 nfet_03v3 ad=3.12p pd=12.52u as=3.12p ps=12.52u w=12u l=0.28u
X46 VDD.t7 XREST.IN_N.t0 VSS.t7 ppolyf_u r_width=2u r_length=5.25u
X47 a_n40400_n37702.t2 F_A3B.t0 VREFL.t11 VSS.t107 nfet_03v3 ad=3.52p pd=16.88u as=2.08p ps=8.52u w=8u l=0.28u
X48 a_n31052_n500.t5 XBANK.XFDAC.CTRL_A VSS.t297 VSS.t283 nfet_03v3 ad=3.9p pd=15.52u as=3.9p ps=15.52u w=15u l=0.28u
X49 a_14628_89200.t5 XREST.OUT_P.t3 a_14228_86600.t6 VSS.t263 nfet_03v3 ad=3.52p pd=16.88u as=2.08p ps=8.52u w=8u l=0.28u
X50 XBANK.XFDAC.CTRL_B a_n13000_n37702.t0 VSS.t132 ppolyf_u r_width=2u r_length=40u
X51 VREFH.t21 G_B0.t1 a_31000_n37702.t0 VSS.t210 nfet_03v3 ad=2.08p pd=8.52u as=3.52p ps=16.88u w=8u l=0.28u
X52 VDD.t16 XBANK.XGAIN.XBUF.INN.t2 VSS.t26 ppolyf_u r_width=2u r_length=6.5u
X53 XBANK.XGDAC.CTRL_A a_12600_n37702.t4 VSS.t267 ppolyf_u r_width=2u r_length=40u
X54 VREFH.t1 F_B3.t1 a_n16000_n37702.t3 VSS.t258 nfet_03v3 ad=2.08p pd=8.52u as=3.52p ps=16.88u w=8u l=0.28u
X55 VSS.t172 XBANK.XGDAC.CTRL_B a_27028_25200.t1 VSS.t165 nfet_03v3 ad=1.04p pd=4.52u as=1.76p ps=8.88u w=4u l=0.28u
X56 VREFH.t16 F_A3.t1 a_n40400_n37702.t3 VSS.t106 nfet_03v3 ad=2.08p pd=8.52u as=3.52p ps=16.88u w=8u l=0.28u
X57 a_15600_n37702.t1 G_A3B.t0 VREFL.t5 VSS.t69 nfet_03v3 ad=3.52p pd=16.88u as=2.08p ps=8.52u w=8u l=0.28u
X58 VDD.t21 XBANK.XGAIN.X2.INP.t3 VSS.t66 ppolyf_u r_width=2u r_length=6.5u
X59 XBANK.XGAIN.XSTART.NODEN.t1 XBANK.XGAIN.XBUF.INN.t4 a_24948_n500.t5 VSS.t64 nfet_03v3 ad=2.2p pd=10.88u as=1.3p ps=5.52u w=5u l=0.28u
X60 a_40000_n37702.t4 G_B3B.t0 VREFL.t38 VSS.t271 nfet_03v3 ad=3.52p pd=16.88u as=2.08p ps=8.52u w=8u l=0.28u
X61 a_n27200_n29600# a_n25000_n37702.t0 VSS.t70 ppolyf_u r_width=2u r_length=40u
X62 VREFH.t17 G_A2.t1 a_18600_n37702.t2 VSS.t159 nfet_03v3 ad=2.08p pd=8.52u as=3.52p ps=16.88u w=8u l=0.28u
X63 a_5028_89200.t0 a_4960_89000.t10 a_3284_89200.t2 VSS.t92 nfet_03v3 ad=1.56p pd=6.52u as=2.64p ps=12.88u w=6u l=0.28u
X64 VREFH.t30 G_B4.t1 a_43000_n37702.t3 VSS.t242 nfet_03v3 ad=2.08p pd=8.52u as=3.52p ps=16.88u w=8u l=0.28u
X65 VSS.t286 XBANK.XFDAC.CTRL_A a_n31052_37900.t6 VSS.t285 nfet_03v3 ad=3.9p pd=15.52u as=3.9p ps=15.52u w=15u l=0.28u
X66 a_23100_n28902# a_24600_n37702.t2 VSS.t191 ppolyf_u r_width=2u r_length=40u
X67 a_13028_89200.t2 a_4960_89000.t8 DIV_P.t1 VSS.t91 nfet_03v3 ad=1.56p pd=6.52u as=2.64p ps=12.88u w=6u l=0.28u
X68 a_n38900_n28902# a_n35900_n28902# VSS.t224 ppolyf_u r_width=2u r_length=20u
X69 a_3428_89200.t5 XREST.OUT_P.t5 a_4628_86600.t3 VSS.t82 nfet_03v3 ad=3.52p pd=16.88u as=2.08p ps=8.52u w=8u l=0.28u
X70 VSS.t277 XBANK.XGAIN.X2.INN.t5 VSS.t276 VSS.t26 nfet_03v3 ad=1.76p pd=8.88u as=0 ps=0 w=4u l=3.45u
X71 VSS.t48 SEL_B.t1 a_n4252_53500.t5 VSS.t47 nfet_03v3 ad=1.3p pd=5.52u as=1.3p ps=5.52u w=5u l=0.28u
X72 a_n28972_25200.t3 XBANK.XFAST.XBUF.INN.t6 XBANK.XFAST.XBUF.INP.t3 VSS.t56 nfet_03v3 ad=1.76p pd=8.88u as=1.76p ps=8.88u w=4u l=0.28u
X73 VDD.t19 XBANK.XFAST.X2.INP.t3 VSS.t53 ppolyf_u r_width=2u r_length=4u
X74 a_35500_n24800# a_32500_n24800# VSS.t249 ppolyf_u r_width=2u r_length=20u
X75 a_n13000_n37702.t2 F_B4.t0 VREFH.t35 VSS.t193 nfet_03v3 ad=3.52p pd=16.88u as=2.08p ps=8.52u w=8u l=0.28u
X76 VSS.t176 DIV_RESET.t3 a_4960_89000.t0 VSS.t175 nfet_03v3 ad=0.52p pd=2.52u as=0.88p ps=4.88u w=2u l=0.28u
X77 VREFL.t9 G_A4B.t1 a_12600_n37702.t0 VSS.t104 nfet_03v3 ad=2.08p pd=8.52u as=3.52p ps=16.88u w=8u l=0.28u
X78 VREFL.t1 F_A2B.t1 a_n37400_n37702.t0 VSS.t0 nfet_03v3 ad=2.08p pd=8.52u as=3.52p ps=16.88u w=8u l=0.28u
X79 a_14228_86600.t3 DIV_BIAS.t2 VSS.t118 VSS.t117 nfet_03v3 ad=2.6p pd=10.52u as=2.6p ps=10.52u w=10u l=0.28u
X80 VSS.t273 XBANK.XFAST.XSTART.NODEP.t6 VSS.t272 VSS.t53 nfet_03v3 ad=1.408p pd=7.28u as=0 ps=0 w=3.2u l=4.48u
X81 XBANK.XFAST.XSTART.NODEP.t1 XBANK.XFAST.XBUF.INP.t4 a_n31052_n500.t1 VSS.t3 nfet_03v3 ad=2.2p pd=10.88u as=1.3p ps=5.52u w=5u l=0.28u
X82 VREFL.t33 F_B1B.t1 a_n22000_n37702.t3 VSS.t222 nfet_03v3 ad=2.08p pd=8.52u as=3.52p ps=16.88u w=8u l=0.28u
X83 a_24948_25100.t3 XBANK.XGDAC.CTRL_A VSS.t147 VSS.t135 nfet_03v3 ad=2.6p pd=10.52u as=2.6p ps=10.52u w=10u l=0.28u
X84 a_27028_n400.t3 XBANK.XGAIN.XSTART.NODEN.t5 XBANK.XGAIN.XSTART.NODEP.t2 VSS.t25 nfet_03v3 ad=1.76p pd=8.88u as=1.76p ps=8.88u w=4u l=0.28u
X85 a_n23500_n24800# a_n27200_n29600# VSS.t102 ppolyf_u r_width=2u r_length=20u
X86 VREFL.t27 G_A0B.t1 a_24600_n37702.t3 VSS.t154 nfet_03v3 ad=2.08p pd=8.52u as=3.52p ps=16.88u w=8u l=0.28u
X87 a_n25000_n37702.t4 F_B0.t0 VREFH.t5 VSS.t241 nfet_03v3 ad=3.52p pd=16.88u as=2.08p ps=8.52u w=8u l=0.28u
X88 a_13028_89200.t0 a_3284_89200.t6 DIV_N.t1 VSS.t41 nfet_03v3 ad=1.56p pd=6.52u as=2.64p ps=12.88u w=6u l=0.28u
X89 a_n5852_53500.t0 XBANK.XSEL.A_P.t9 a_n5996_53500.t4 VSS.t5 nfet_03v3 ad=1.3p pd=5.52u as=2.2p ps=10.88u w=5u l=0.28u
X90 a_1748_53500.t10 a_n2796_53500.t10 XREST.IN_N.t3 VSS.t246 nfet_03v3 ad=1.3p pd=5.52u as=2.2p ps=10.88u w=5u l=0.28u
X91 XBANK.XSEL.A_P.t3 XBANK.XFAST.XBUF.INP.t8 a_n31052_37900.t0 VSS.t3 nfet_03v3 ad=2.2p pd=10.88u as=1.3p ps=5.52u w=5u l=0.28u
X92 a_24948_37900.t6 XBANK.XGAIN.XBUF.INN.t9 XBANK.XSEL.B_N.t1 VSS.t93 nfet_03v3 ad=1.3p pd=5.52u as=2.2p ps=10.88u w=5u l=0.28u
X93 a_n28972_25200.t2 XBANK.XFAST.XBUF.INP.t6 XBANK.XFAST.XBUF.INN.t1 VSS.t158 nfet_03v3 ad=1.76p pd=8.88u as=1.76p ps=8.88u w=4u l=0.28u
X94 a_12600_n37702.t3 G_A4.t0 VREFH.t12 VSS.t105 nfet_03v3 ad=3.52p pd=16.88u as=2.08p ps=8.52u w=8u l=0.28u
X95 a_20100_n28902# a_23100_n28902# VSS.t234 ppolyf_u r_width=2u r_length=20u
X96 a_4960_89000.t5 a_3284_89200.t7 a_5028_89200.t3 VSS.t257 nfet_03v3 ad=2.64p pd=12.88u as=1.56p ps=6.52u w=6u l=0.28u
X97 a_n31052_25100.t5 XBANK.XFDAC.CTRL_A VSS.t292 VSS.t283 nfet_03v3 ad=3.9p pd=15.52u as=3.9p ps=15.52u w=15u l=0.28u
X98 a_n31052_n500.t0 XBANK.XFAST.XBUF.INP.t5 XBANK.XFAST.XSTART.NODEP.t0 VSS.t2 nfet_03v3 ad=1.3p pd=5.52u as=2.2p ps=10.88u w=5u l=0.28u
X99 a_n34400_n37702.t4 F_A1B.t0 VREFL.t42 VSS.t34 nfet_03v3 ad=3.52p pd=16.88u as=2.08p ps=8.52u w=8u l=0.28u
X100 DIV_P.t5 DIV_N.t5 a_14628_89200.t1 VSS.t186 nfet_03v3 ad=2.64p pd=12.88u as=1.56p ps=6.52u w=6u l=0.28u
X101 a_n31052_25100.t3 XBANK.XFAST.X2.INP.t7 XBANK.XFAST.XBUF.INP.t0 VSS.t2 nfet_03v3 ad=1.3p pd=5.52u as=2.2p ps=10.88u w=5u l=0.28u
X102 XBANK.XGAIN.XBUF.INN.t1 XBANK.XGAIN.X2.INN.t6 a_24948_25100.t1 VSS.t64 nfet_03v3 ad=2.2p pd=10.88u as=1.3p ps=5.52u w=5u l=0.28u
X103 a_24600_n37702.t1 G_A0.t0 VREFH.t11 VSS.t155 nfet_03v3 ad=3.52p pd=16.88u as=2.08p ps=8.52u w=8u l=0.28u
X104 a_n28972_n400.t1 XBANK.XFDAC.CTRL_B VSS.t80 VSS.t76 nfet_03v3 ad=2.64p pd=12.88u as=1.56p ps=6.52u w=6u l=0.28u
X105 a_n5996_53500.t7 XBANK.XSEL.A_P.t6 a_n5852_53500.t3 VSS.t60 nfet_03v3 ad=2.2p pd=10.88u as=1.3p ps=5.52u w=5u l=0.28u
X106 a_n2796_53500.t1 XBANK.XSEL.A_N.t8 a_n5852_53500.t1 VSS.t23 nfet_03v3 ad=2.2p pd=10.88u as=1.3p ps=5.52u w=5u l=0.28u
X107 VSS.t195 XBANK.XFAST.XBUF.INN.t7 VSS.t194 VSS.t6 nfet_03v3 ad=1.408p pd=7.28u as=0 ps=0 w=3.2u l=4.48u
X108 a_n31052_12300.t3 XBANK.XFAST.XSTART.NODEN.t8 XBANK.XFAST.X2.INN.t2 VSS.t22 nfet_03v3 ad=1.3p pd=5.52u as=2.2p ps=10.88u w=5u l=0.28u
X109 XBANK.XGAIN.X2.INP.t2 XBANK.XGAIN.XSTART.NODEP.t7 a_24948_12300.t0 VSS.t59 nfet_03v3 ad=2.2p pd=10.88u as=1.3p ps=5.52u w=5u l=0.28u
X110 VSS.t166 XBANK.XGDAC.CTRL_B a_27028_12400.t0 VSS.t165 nfet_03v3 ad=1.04p pd=4.52u as=1.76p ps=8.88u w=4u l=0.28u
X111 a_n32900_n28902# a_n31400_n37702.t0 VSS.t103 ppolyf_u r_width=2u r_length=40u
X112 VDD.t4 DIV_P.t0 VSS.t42 ppolyf_u r_width=2u r_length=7.5u
X113 VSS.t44 SEL_B.t3 a_n4252_53500.t3 VSS.t43 nfet_03v3 ad=1.3p pd=5.52u as=2.2p ps=10.88u w=5u l=0.28u
X114 XBANK.XFAST.XBUF.INN.t3 XBANK.XFAST.X2.INN.t6 a_n31052_25100.t1 VSS.t236 nfet_03v3 ad=2.2p pd=10.88u as=1.3p ps=5.52u w=5u l=0.28u
X115 a_24948_25100.t6 XBANK.XGAIN.X2.INP.t7 XBANK.XGAIN.XBUF.INP.t2 VSS.t39 nfet_03v3 ad=1.3p pd=5.52u as=2.2p ps=10.88u w=5u l=0.28u
X116 a_27028_25200.t3 XBANK.XGAIN.XBUF.INP.t6 XBANK.XGAIN.XBUF.INN.t3 VSS.t94 nfet_03v3 ad=1.76p pd=8.88u as=1.76p ps=8.88u w=4u l=0.28u
X117 VSS.t298 XBANK.XFDAC.CTRL_A a_n31052_n500.t6 VSS.t285 nfet_03v3 ad=3.9p pd=15.52u as=3.9p ps=15.52u w=15u l=0.28u
X118 a_14228_86600.t7 XREST.OUT_P.t4 a_14628_89200.t4 VSS.t264 nfet_03v3 ad=2.08p pd=8.52u as=3.52p ps=16.88u w=8u l=0.28u
X119 a_n5852_53500.t8 SEL_A.t2 VSS.t206 VSS.t45 nfet_03v3 ad=1.3p pd=5.52u as=1.3p ps=5.52u w=5u l=0.28u
X120 a_34000_n37702.t1 G_B1B.t0 VREFL.t7 VSS.t99 nfet_03v3 ad=3.52p pd=16.88u as=2.08p ps=8.52u w=8u l=0.28u
X121 a_28800_n29600# a_31000_n37702.t4 VSS.t301 ppolyf_u r_width=2u r_length=40u
X122 VREFH.t33 F_A1.t1 a_n34400_n37702.t0 VSS.t33 nfet_03v3 ad=2.08p pd=8.52u as=3.52p ps=16.88u w=8u l=0.28u
X123 VDD.t15 a_n2796_53500.t4 VSS.t190 ppolyf_u r_width=2u r_length=4u
X124 a_n4252_53500.t1 XBANK.XSEL.B_N.t7 a_n2796_53500.t7 VSS.t29 nfet_03v3 ad=1.3p pd=5.52u as=2.2p ps=10.88u w=5u l=0.28u
X125 VSS.t86 XBANK.XGAIN.XSTART.NODEN.t6 VSS.t85 VSS.t26 nfet_03v3 ad=1.76p pd=8.88u as=0 ps=0 w=4u l=3.45u
X126 a_n20500_n24800# a_n19000_n37702.t4 VSS.t238 ppolyf_u r_width=2u r_length=40u
X127 VREFH.t22 G_B2.t1 a_37000_n37702.t1 VSS.t228 nfet_03v3 ad=2.08p pd=8.52u as=3.52p ps=16.88u w=8u l=0.28u
X128 VDD.t26 XBANK.XSEL.B_N.t3 VSS.t26 ppolyf_u r_width=2u r_length=6.5u
X129 a_24948_12300.t6 XBANK.XGDAC.CTRL_A VSS.t148 VSS.t142 nfet_03v3 ad=4.4p pd=20.88u as=2.6p ps=10.52u w=10u l=0.28u
X130 VDD.t22 XBANK.XGAIN.XSTART.NODEN.t4 VSS.t26 ppolyf_u r_width=2u r_length=6.5u
X131 XBANK.XFDAC.CTRL_A a_n43400_n37702.t0 VSS.t90 ppolyf_u r_width=2u r_length=40u
X132 a_n32900_n28902# VREFL.t13 VSS.t56 ppolyf_u r_width=2u r_length=40u
X133 a_1748_53500.t5 SEL_BUF.t2 VSS.t231 VSS.t13 nfet_03v3 ad=2.6p pd=10.52u as=2.6p ps=10.52u w=10u l=0.28u
X134 VREFH.t8 G_A1.t1 a_21600_n37702.t3 VSS.t31 nfet_03v3 ad=2.08p pd=8.52u as=3.52p ps=16.88u w=8u l=0.28u
X135 a_17100_n28902# a_18600_n37702.t4 VSS.t213 ppolyf_u r_width=2u r_length=40u
X136 a_27028_25200.t0 XBANK.XGAIN.XBUF.INN.t6 XBANK.XGAIN.XBUF.INP.t1 VSS.t25 nfet_03v3 ad=1.76p pd=8.88u as=1.76p ps=8.88u w=4u l=0.28u
X137 XBANK.XGDAC.CTRL_B a_43000_n37702.t0 VSS.t217 ppolyf_u r_width=2u r_length=40u
X138 VSS.t216 FAST_KICKP.t0 XBANK.XFAST.XSTART.NODEP.t3 VSS.t215 nfet_03v3 ad=0.44p pd=2.88u as=0.44p ps=2.88u w=1u l=0.28u
X139 VSS.t221 GAIN_KICKN.t0 XBANK.XGAIN.XSTART.NODEN.t2 VSS.t220 nfet_03v3 ad=0.44p pd=2.88u as=0.44p ps=2.88u w=1u l=0.28u
X140 VDD.t1 a_3600_70348.t0 VSS.t7 ppolyf_u r_width=2u r_length=7.5u
X141 a_n31052_37900.t7 XBANK.XFDAC.CTRL_A VSS.t288 VSS.t287 nfet_03v3 ad=6.6p pd=30.88u as=3.9p ps=15.52u w=15u l=0.28u
X142 a_4628_86600.t2 XREST.OUT_P.t6 a_3428_89200.t4 VSS.t81 nfet_03v3 ad=2.08p pd=8.52u as=3.52p ps=16.88u w=8u l=0.28u
X143 VDD.t11 XREST.OUT_P.t0 VSS.t153 ppolyf_u r_width=2u r_length=7.5u
X144 a_2148_67400.t1 REST_BIAS.t2 VSS.t19 VSS.t13 nfet_03v3 ad=3.12p pd=12.52u as=3.12p ps=12.52u w=12u l=0.28u
X145 a_n4252_53500.t6 SEL_B.t0 VSS.t50 VSS.t49 nfet_03v3 ad=2.2p pd=10.88u as=1.3p ps=5.52u w=5u l=0.28u
X146 VREFL.t20 G_B0B.t1 a_31000_n37702.t2 VSS.t210 nfet_03v3 ad=2.08p pd=8.52u as=3.52p ps=16.88u w=8u l=0.28u
X147 a_n31400_n37702.t4 F_A0.t0 VREFH.t3 VSS.t227 nfet_03v3 ad=3.52p pd=16.88u as=2.08p ps=8.52u w=8u l=0.28u
X148 XREST.OUT_P.t2 a_2000_70348.t3 a_2148_76800.t7 VSS.t58 nfet_03v3 ad=4.4p pd=20.88u as=2.6p ps=10.52u w=10u l=0.28u
X149 a_27028_n400.t2 XBANK.XGDAC.CTRL_B VSS.t174 VSS.t168 nfet_03v3 ad=1.76p pd=8.88u as=1.04p ps=4.52u w=4u l=0.28u
X150 VSS.t282 XBANK.XFDAC.CTRL_A a_n31052_37900.t4 VSS.t280 nfet_03v3 ad=3.9p pd=15.52u as=6.6p ps=30.88u w=15u l=0.28u
X151 VREFL.t35 F_B3B.t1 a_n16000_n37702.t0 VSS.t258 nfet_03v3 ad=2.08p pd=8.52u as=3.52p ps=16.88u w=8u l=0.28u
X152 VSS.t139 XBANK.XGDAC.CTRL_A a_24948_37900.t0 VSS.t137 nfet_03v3 ad=2.6p pd=10.52u as=4.4p ps=20.88u w=10u l=0.28u
X153 a_n17500_n24800# a_n20500_n24800# VSS.t95 ppolyf_u r_width=2u r_length=20u
X154 VREFL.t12 F_A3B.t1 a_n40400_n37702.t1 VSS.t106 nfet_03v3 ad=2.08p pd=8.52u as=3.52p ps=16.88u w=8u l=0.28u
X155 VSS.t116 DIV_BIAS.t7 a_4628_86600.t4 VSS.t115 nfet_03v3 ad=2.6p pd=10.52u as=4.4p ps=20.88u w=10u l=0.28u
X156 a_2148_76800.t1 REST_BIAS.t6 VSS.t14 VSS.t13 nfet_03v3 ad=3.12p pd=12.52u as=3.12p ps=12.52u w=12u l=0.28u
X157 a_2000_70348.t1 XREST.IN_P.t5 a_2148_67400.t6 VSS.t58 nfet_03v3 ad=4.4p pd=20.88u as=2.6p ps=10.52u w=10u l=0.28u
X158 VREFL.t16 G_A2B.t1 a_18600_n37702.t0 VSS.t159 nfet_03v3 ad=2.08p pd=8.52u as=3.52p ps=16.88u w=8u l=0.28u
X159 a_n19000_n37702.t1 F_B2.t0 VREFH.t19 VSS.t157 nfet_03v3 ad=3.52p pd=16.88u as=2.08p ps=8.52u w=8u l=0.28u
X160 VDD.t24 XBANK.XGAIN.X2.INN.t2 VSS.t26 ppolyf_u r_width=2u r_length=6.5u
X161 a_n43400_n37702.t2 F_A4.t0 VREFH.t24 VSS.t101 nfet_03v3 ad=3.52p pd=16.88u as=2.08p ps=8.52u w=8u l=0.28u
X162 VREFL.t30 G_B4B.t1 a_43000_n37702.t1 VSS.t242 nfet_03v3 ad=2.08p pd=8.52u as=3.52p ps=16.88u w=8u l=0.28u
X163 a_14100_n28902# a_17100_n28902# VSS.t214 ppolyf_u r_width=2u r_length=20u
X164 VDD.t9 XBANK.XFAST.XSTART.NODEN.t1 VSS.t6 ppolyf_u r_width=2u r_length=4u
X165 a_31000_n37702.t1 G_B0.t0 VREFH.t20 VSS.t211 nfet_03v3 ad=3.52p pd=16.88u as=2.08p ps=8.52u w=8u l=0.28u
X166 a_24948_37900.t3 XBANK.XGDAC.CTRL_A VSS.t146 VSS.t142 nfet_03v3 ad=4.4p pd=20.88u as=2.6p ps=10.52u w=10u l=0.28u
X167 a_14228_86600.t5 DIV_BIAS.t0 VSS.t119 VSS.t68 nfet_03v3 ad=4.4p pd=20.88u as=2.6p ps=10.52u w=10u l=0.28u
X168 a_n5996_53500.t5 XBANK.XSEL.A_P.t8 a_n5852_53500.t11 VSS.t244 nfet_03v3 ad=2.2p pd=10.88u as=1.3p ps=5.52u w=5u l=0.28u
X169 VSS.t281 XBANK.XFDAC.CTRL_A a_n31052_12300.t4 VSS.t280 nfet_03v3 ad=3.9p pd=15.52u as=6.6p ps=30.88u w=15u l=0.28u
X170 a_18600_n37702.t3 G_A2.t0 VREFH.t18 VSS.t160 nfet_03v3 ad=3.52p pd=16.88u as=2.08p ps=8.52u w=8u l=0.28u
X171 a_5028_89200.t5 a_3284_89200.t8 a_4960_89000.t6 VSS.t269 nfet_03v3 ad=1.56p pd=6.52u as=2.64p ps=12.88u w=6u l=0.28u
X172 a_43000_n37702.t4 G_B4.t0 VREFH.t31 VSS.t243 nfet_03v3 ad=3.52p pd=16.88u as=2.08p ps=8.52u w=8u l=0.28u
X173 VSS.t72 XBANK.XFDAC.CTRL_B a_n28972_38000.t1 VSS.t71 nfet_03v3 ad=1.56p pd=6.52u as=2.64p ps=12.88u w=6u l=0.28u
X174 VSS.t289 XBANK.XFDAC.CTRL_A a_n31052_25100.t6 VSS.t285 nfet_03v3 ad=3.9p pd=15.52u as=3.9p ps=15.52u w=15u l=0.28u
X175 a_n13000_n37702.t4 F_B4B.t0 VREFL.t18 VSS.t193 nfet_03v3 ad=3.52p pd=16.88u as=2.08p ps=8.52u w=8u l=0.28u
X176 a_14628_89200.t0 DIV_N.t6 DIV_P.t6 VSS.t185 nfet_03v3 ad=1.56p pd=6.52u as=2.64p ps=12.88u w=6u l=0.28u
X177 a_n4252_53500.t11 XBANK.XSEL.B_N.t9 a_n2796_53500.t5 VSS.t204 nfet_03v3 ad=1.3p pd=5.52u as=2.2p ps=10.88u w=5u l=0.28u
X178 a_n31052_12300.t5 XBANK.XFDAC.CTRL_A VSS.t293 VSS.t283 nfet_03v3 ad=3.9p pd=15.52u as=3.9p ps=15.52u w=15u l=0.28u
X179 a_3284_89200.t1 DIV_P.t9 a_3428_89200.t2 VSS.t201 nfet_03v3 ad=2.64p pd=12.88u as=1.56p ps=6.52u w=6u l=0.28u
X180 a_n28972_12400.t2 XBANK.XFAST.X2.INN.t4 XBANK.XFAST.X2.INP.t2 VSS.t56 nfet_03v3 ad=1.76p pd=8.88u as=1.76p ps=8.88u w=4u l=0.28u
X181 a_n25000_n37702.t2 F_B0B.t0 VREFL.t28 VSS.t241 nfet_03v3 ad=3.52p pd=16.88u as=2.08p ps=8.52u w=8u l=0.28u
X182 a_13028_89200.t5 XREST.OUT_N.t3 a_14228_86600.t0 VSS.t8 nfet_03v3 ad=3.52p pd=16.88u as=2.08p ps=8.52u w=8u l=0.28u
X183 VSS.t251 XBANK.XSEL.A_N.t5 VSS.t250 VSS.t6 nfet_03v3 ad=1.408p pd=7.28u as=0 ps=0 w=3.2u l=4.48u
X184 a_n28972_n400.t2 XBANK.XFAST.XSTART.NODEN.t5 XBANK.XFAST.XSTART.NODEP.t4 VSS.t56 nfet_03v3 ad=1.76p pd=8.88u as=1.76p ps=8.88u w=4u l=0.28u
X185 a_12600_n37702.t1 G_A4B.t0 VREFL.t10 VSS.t105 nfet_03v3 ad=3.52p pd=16.88u as=2.08p ps=8.52u w=8u l=0.28u
X186 VREFH.t4 F_B4.t1 a_n13000_n37702.t1 VSS.t192 nfet_03v3 ad=2.08p pd=8.52u as=3.52p ps=16.88u w=8u l=0.28u
X187 VSS.t75 XBANK.XFDAC.CTRL_B a_n28972_12400.t0 VSS.t71 nfet_03v3 ad=1.56p pd=6.52u as=2.64p ps=12.88u w=6u l=0.28u
X188 a_n31052_n500.t7 XBANK.XFDAC.CTRL_A VSS.t299 VSS.t287 nfet_03v3 ad=6.6p pd=30.88u as=3.9p ps=15.52u w=15u l=0.28u
X189 a_n38900_n28902# a_n37400_n37702.t2 VSS.t109 ppolyf_u r_width=2u r_length=40u
X190 VREFH.t6 G_A3.t1 a_15600_n37702.t2 VSS.t68 nfet_03v3 ad=2.08p pd=8.52u as=3.52p ps=16.88u w=8u l=0.28u
X191 a_23100_n28902# VREFL.t17 VSS.t25 ppolyf_u r_width=2u r_length=40u
X192 VDD.t3 XBANK.XFAST.XBUF.INN.t0 VSS.t6 ppolyf_u r_width=2u r_length=4u
X193 a_n23500_n24800# a_n22000_n37702.t0 VSS.t189 ppolyf_u r_width=2u r_length=40u
X194 VREFH.t37 G_B3.t1 a_40000_n37702.t1 VSS.t270 nfet_03v3 ad=2.08p pd=8.52u as=3.52p ps=16.88u w=8u l=0.28u
X195 a_35500_n24800# a_37000_n37702.t0 VSS.t212 ppolyf_u r_width=2u r_length=40u
X196 a_n2796_53500.t8 XBANK.XSEL.B_N.t6 a_n4252_53500.t0 VSS.t4 nfet_03v3 ad=2.2p pd=10.88u as=1.3p ps=5.52u w=5u l=0.28u
X197 XREST.IN_P.t1 a_n5996_53500.t11 a_1748_53500.t11 VSS.t255 nfet_03v3 ad=2.2p pd=10.88u as=1.3p ps=5.52u w=5u l=0.28u
X198 a_n28972_12400.t3 XBANK.XFAST.X2.INP.t4 XBANK.XFAST.X2.INN.t1 VSS.t158 nfet_03v3 ad=1.76p pd=8.88u as=1.76p ps=8.88u w=4u l=0.28u
X199 VSS.t295 XBANK.XFDAC.CTRL_A a_n31052_n500.t4 VSS.t280 nfet_03v3 ad=3.9p pd=15.52u as=6.6p ps=30.88u w=15u l=0.28u
X200 a_24600_n37702.t4 G_A0B.t0 VREFL.t26 VSS.t155 nfet_03v3 ad=3.52p pd=16.88u as=2.08p ps=8.52u w=8u l=0.28u
X201 a_20100_n28902# a_21600_n37702.t2 VSS.t110 ppolyf_u r_width=2u r_length=40u
X202 VREFH.t32 F_B0.t1 a_n25000_n37702.t3 VSS.t240 nfet_03v3 ad=2.08p pd=8.52u as=3.52p ps=16.88u w=8u l=0.28u
X203 a_n35900_n28902# a_n32900_n28902# VSS.t112 ppolyf_u r_width=2u r_length=20u
X204 VSS.t261 XBANK.XGAIN.XBUF.INP.t7 VSS.t260 VSS.t66 nfet_03v3 ad=1.76p pd=8.88u as=0 ps=0 w=4u l=3.45u
X205 a_4960_89000.t3 DIV_N.t7 a_3428_89200.t1 VSS.t184 nfet_03v3 ad=2.64p pd=12.88u as=1.56p ps=6.52u w=6u l=0.28u
X206 a_32500_n24800# a_28800_n29600# VSS.t300 ppolyf_u r_width=2u r_length=20u
X207 VSS.t55 XBANK.XFAST.XBUF.INP.t7 VSS.t54 VSS.t53 nfet_03v3 ad=1.408p pd=7.28u as=0 ps=0 w=3.2u l=4.48u
X208 a_n31052_12300.t0 XBANK.XFAST.XSTART.NODEP.t8 XBANK.XFAST.X2.INP.t0 VSS.t2 nfet_03v3 ad=1.3p pd=5.52u as=2.2p ps=10.88u w=5u l=0.28u
X209 XBANK.XGAIN.X2.INN.t1 XBANK.XGAIN.XSTART.NODEN.t7 a_24948_12300.t1 VSS.t64 nfet_03v3 ad=2.2p pd=10.88u as=1.3p ps=5.52u w=5u l=0.28u
X210 VREFL.t43 F_A1B.t1 a_n34400_n37702.t3 VSS.t33 nfet_03v3 ad=2.08p pd=8.52u as=3.52p ps=16.88u w=8u l=0.28u
X211 DIV_N.t2 DIV_P.t7 a_14628_89200.t3 VSS.t203 nfet_03v3 ad=2.64p pd=12.88u as=1.56p ps=6.52u w=6u l=0.28u
X212 VSS.t150 XBANK.XGDAC.CTRL_A a_24948_n500.t1 VSS.t137 nfet_03v3 ad=2.6p pd=10.52u as=4.4p ps=20.88u w=10u l=0.28u
X213 VDD.t17 a_4960_89000.t4 VSS.t199 ppolyf_u r_width=2u r_length=7.5u
X214 a_2148_76800.t6 a_2000_70348.t4 XREST.OUT_P.t1 VSS.t61 nfet_03v3 ad=2.6p pd=10.52u as=4.4p ps=20.88u w=10u l=0.28u
X215 a_27028_38000.t3 XBANK.XGDAC.CTRL_B VSS.t170 VSS.t168 nfet_03v3 ad=1.76p pd=8.88u as=1.04p ps=4.52u w=4u l=0.28u
X216 XBANK.XFAST.XBUF.INP.t1 XBANK.XFAST.X2.INP.t6 a_n31052_25100.t2 VSS.t3 nfet_03v3 ad=2.2p pd=10.88u as=1.3p ps=5.52u w=5u l=0.28u
X217 a_24948_25100.t0 XBANK.XGAIN.X2.INN.t7 XBANK.XGAIN.XBUF.INN.t0 VSS.t93 nfet_03v3 ad=1.3p pd=5.52u as=2.2p ps=10.88u w=5u l=0.28u
X218 VSS.t248 XBANK.XFAST.X2.INN.t5 VSS.t247 VSS.t6 nfet_03v3 ad=1.408p pd=7.28u as=0 ps=0 w=3.2u l=4.48u
X219 VSS.t167 XBANK.XGDAC.CTRL_B a_27028_n400.t1 VSS.t165 nfet_03v3 ad=1.04p pd=4.52u as=1.76p ps=8.88u w=4u l=0.28u
X220 VREFL.t41 G_B2B.t1 a_37000_n37702.t3 VSS.t228 nfet_03v3 ad=2.08p pd=8.52u as=3.52p ps=16.88u w=8u l=0.28u
X221 a_n37400_n37702.t4 F_A2.t0 VREFH.t15 VSS.t1 nfet_03v3 ad=3.52p pd=16.88u as=2.08p ps=8.52u w=8u l=0.28u
X222 a_n20500_n24800# a_n23500_n24800# VSS.t63 ppolyf_u r_width=2u r_length=20u
X223 a_2148_67400.t7 XREST.IN_P.t6 a_2000_70348.t0 VSS.t61 nfet_03v3 ad=2.6p pd=10.52u as=4.4p ps=20.88u w=10u l=0.28u
X224 XBANK.XFAST.X2.INN.t3 XBANK.XFAST.XSTART.NODEN.t7 a_n31052_12300.t2 VSS.t236 nfet_03v3 ad=2.2p pd=10.88u as=1.3p ps=5.52u w=5u l=0.28u
X225 a_24948_12300.t7 XBANK.XGAIN.XSTART.NODEP.t8 XBANK.XGAIN.X2.INP.t1 VSS.t39 nfet_03v3 ad=1.3p pd=5.52u as=2.2p ps=10.88u w=5u l=0.28u
X226 a_27028_12400.t3 XBANK.XGAIN.X2.INP.t4 XBANK.XGAIN.X2.INN.t3 VSS.t94 nfet_03v3 ad=1.76p pd=8.88u as=1.76p ps=8.88u w=4u l=0.28u
X227 VREFL.t2 G_A1B.t1 a_21600_n37702.t0 VSS.t31 nfet_03v3 ad=2.08p pd=8.52u as=3.52p ps=16.88u w=8u l=0.28u
X228 a_n22000_n37702.t2 F_B1.t0 VREFH.t39 VSS.t223 nfet_03v3 ad=3.52p pd=16.88u as=2.08p ps=8.52u w=8u l=0.28u
X229 a_n31052_37900.t2 XBANK.XFAST.XBUF.INN.t9 XBANK.XSEL.A_N.t2 VSS.t22 nfet_03v3 ad=1.3p pd=5.52u as=2.2p ps=10.88u w=5u l=0.28u
X230 XBANK.XSEL.B_P.t1 XBANK.XGAIN.XBUF.INP.t8 a_24948_37900.t7 VSS.t59 nfet_03v3 ad=2.2p pd=10.88u as=1.3p ps=5.52u w=5u l=0.28u
X231 VSS.t151 XBANK.XGDAC.CTRL_A a_24948_12300.t5 VSS.t133 nfet_03v3 ad=2.6p pd=10.52u as=2.6p ps=10.52u w=10u l=0.28u
X232 a_24948_n500.t4 XBANK.XGDAC.CTRL_A VSS.t152 VSS.t142 nfet_03v3 ad=4.4p pd=20.88u as=2.6p ps=10.52u w=10u l=0.28u
X233 a_17100_n28902# a_20100_n28902# VSS.t87 ppolyf_u r_width=2u r_length=20u
X234 VSS.t207 SEL_A.t1 a_n5852_53500.t9 VSS.t47 nfet_03v3 ad=1.3p pd=5.52u as=1.3p ps=5.52u w=5u l=0.28u
X235 a_5028_89200.t2 XREST.OUT_N.t5 a_4628_86600.t1 VSS.t62 nfet_03v3 ad=3.52p pd=16.88u as=2.08p ps=8.52u w=8u l=0.28u
X236 VDD.t27 XREST.IN_P.t4 VSS.t153 ppolyf_u r_width=2u r_length=5.25u
X237 a_n4252_53500.t10 XBANK.XSEL.B_P.t7 a_n5996_53500.t2 VSS.t196 nfet_03v3 ad=1.3p pd=5.52u as=2.2p ps=10.88u w=5u l=0.28u
X238 VSS.t145 XBANK.XGDAC.CTRL_A a_24948_37900.t2 VSS.t133 nfet_03v3 ad=2.6p pd=10.52u as=2.6p ps=10.52u w=10u l=0.28u
X239 a_37000_n37702.t2 G_B2.t0 VREFH.t23 VSS.t229 nfet_03v3 ad=3.52p pd=16.88u as=2.08p ps=8.52u w=8u l=0.28u
X240 VSS.t123 DIV_BIAS.t5 a_4628_86600.t6 VSS.t122 nfet_03v3 ad=2.6p pd=10.52u as=2.6p ps=10.52u w=10u l=0.28u
X241 a_27028_12400.t2 XBANK.XGAIN.X2.INN.t4 XBANK.XGAIN.X2.INP.t0 VSS.t25 nfet_03v3 ad=1.76p pd=8.88u as=1.76p ps=8.88u w=4u l=0.28u
X242 a_n31400_n37702.t2 F_A0B.t0 VREFL.t25 VSS.t227 nfet_03v3 ad=3.52p pd=16.88u as=2.08p ps=8.52u w=8u l=0.28u
X243 a_21600_n37702.t4 G_A1.t0 VREFH.t9 VSS.t32 nfet_03v3 ad=3.52p pd=16.88u as=2.08p ps=8.52u w=8u l=0.28u
X244 a_n31052_25100.t7 XBANK.XFDAC.CTRL_A VSS.t290 VSS.t287 nfet_03v3 ad=6.6p pd=30.88u as=3.9p ps=15.52u w=15u l=0.28u
X245 a_n28972_38000.t2 XBANK.XFDAC.CTRL_B VSS.t77 VSS.t76 nfet_03v3 ad=2.64p pd=12.88u as=1.56p ps=6.52u w=6u l=0.28u
X246 a_n28972_n400.t3 XBANK.XFAST.XSTART.NODEP.t5 XBANK.XFAST.XSTART.NODEN.t2 VSS.t158 nfet_03v3 ad=1.76p pd=8.88u as=1.76p ps=8.88u w=4u l=0.28u
X247 a_n19000_n37702.t3 F_B2B.t0 VREFL.t22 VSS.t157 nfet_03v3 ad=3.52p pd=16.88u as=2.08p ps=8.52u w=8u l=0.28u
X248 a_n2796_53500.t6 XBANK.XSEL.B_N.t8 a_n4252_53500.t8 VSS.t65 nfet_03v3 ad=2.2p pd=10.88u as=1.3p ps=5.52u w=5u l=0.28u
X249 a_n43400_n37702.t4 F_A4B.t0 VREFL.t36 VSS.t101 nfet_03v3 ad=3.52p pd=16.88u as=2.08p ps=8.52u w=8u l=0.28u
X250 XREST.IN_P.t3 a_n5996_53500.t9 a_1748_53500.t1 VSS.t89 nfet_03v3 ad=2.2p pd=10.88u as=1.3p ps=5.52u w=5u l=0.28u
X251 VSS.t291 XBANK.XFDAC.CTRL_A a_n31052_25100.t4 VSS.t280 nfet_03v3 ad=3.9p pd=15.52u as=6.6p ps=30.88u w=15u l=0.28u
X252 a_31000_n37702.t3 G_B0B.t0 VREFL.t21 VSS.t211 nfet_03v3 ad=3.52p pd=16.88u as=2.08p ps=8.52u w=8u l=0.28u
X253 VREFH.t34 F_A0.t1 a_n31400_n37702.t3 VSS.t226 nfet_03v3 ad=2.08p pd=8.52u as=3.52p ps=16.88u w=8u l=0.28u
X254 a_3428_89200.t3 DIV_P.t10 a_3284_89200.t0 VSS.t200 nfet_03v3 ad=1.56p pd=6.52u as=2.64p ps=12.88u w=6u l=0.28u
X255 a_14228_86600.t1 XREST.OUT_N.t4 a_13028_89200.t4 VSS.t9 nfet_03v3 ad=2.08p pd=8.52u as=3.52p ps=16.88u w=8u l=0.28u
X256 a_n17500_n24800# a_n16000_n37702.t2 VSS.t266 ppolyf_u r_width=2u r_length=40u
X257 VREFH.t28 G_B1.t1 a_34000_n37702.t3 VSS.t98 nfet_03v3 ad=2.08p pd=8.52u as=3.52p ps=16.88u w=8u l=0.28u
X258 a_n41900_n28902# a_n40400_n37702.t0 VSS.t37 ppolyf_u r_width=2u r_length=40u
X259 VREFH.t0 F_B2.t1 a_n19000_n37702.t0 VSS.t156 nfet_03v3 ad=2.08p pd=8.52u as=3.52p ps=16.88u w=8u l=0.28u
X260 VREFH.t25 F_A4.t1 a_n43400_n37702.t1 VSS.t100 nfet_03v3 ad=2.08p pd=8.52u as=3.52p ps=16.88u w=8u l=0.28u
X261 a_18600_n37702.t1 G_A2B.t0 VREFL.t15 VSS.t160 nfet_03v3 ad=3.52p pd=16.88u as=2.08p ps=8.52u w=8u l=0.28u
X262 a_14100_n28902# a_15600_n37702.t4 VSS.t209 ppolyf_u r_width=2u r_length=40u
X263 a_24948_n500.t0 XBANK.XGAIN.XBUF.INP.t5 XBANK.XGAIN.XSTART.NODEP.t0 VSS.t39 nfet_03v3 ad=1.3p pd=5.52u as=2.2p ps=10.88u w=5u l=0.28u
X264 a_43000_n37702.t2 G_B4B.t0 VREFL.t31 VSS.t243 nfet_03v3 ad=3.52p pd=16.88u as=2.08p ps=8.52u w=8u l=0.28u
X265 a_38500_n24800# a_40000_n37702.t0 VSS.t262 ppolyf_u r_width=2u r_length=40u
X266 VSS.t125 DIV_BIAS.t3 a_14228_86600.t2 VSS.t124 nfet_03v3 ad=2.6p pd=10.52u as=4.4p ps=20.88u w=10u l=0.28u
X267 a_1748_53500.t8 a_n5996_53500.t12 XREST.IN_P.t0 VSS.t235 nfet_03v3 ad=1.3p pd=5.52u as=2.2p ps=10.88u w=5u l=0.28u
X268 VDD.t0 XBANK.XSEL.A_N.t0 VSS.t6 ppolyf_u r_width=2u r_length=4u
X269 VSS.t205 SEL_A.t3 a_n5852_53500.t7 VSS.t43 nfet_03v3 ad=1.3p pd=5.52u as=2.2p ps=10.88u w=5u l=0.28u
X270 VSS.t144 XBANK.XGDAC.CTRL_A a_24948_25100.t2 VSS.t137 nfet_03v3 ad=2.6p pd=10.52u as=4.4p ps=20.88u w=10u l=0.28u
X271 VSS.t294 XBANK.XFDAC.CTRL_A a_n31052_12300.t6 VSS.t285 nfet_03v3 ad=3.9p pd=15.52u as=3.9p ps=15.52u w=15u l=0.28u
X272 VDD.t10 XBANK.XFAST.XSTART.NODEP.t2 VSS.t53 ppolyf_u r_width=2u r_length=4u
X273 a_3428_89200.t0 DIV_N.t8 a_4960_89000.t2 VSS.t183 nfet_03v3 ad=1.56p pd=6.52u as=2.64p ps=12.88u w=6u l=0.28u
X274 VSS.t74 XBANK.XFDAC.CTRL_B a_n28972_25200.t0 VSS.t71 nfet_03v3 ad=1.56p pd=6.52u as=2.64p ps=12.88u w=6u l=0.28u
X275 a_n41900_n28902# a_n38900_n28902# VSS.t197 ppolyf_u r_width=2u r_length=20u
X276 VREFL.t19 F_B4B.t1 a_n13000_n37702.t3 VSS.t192 nfet_03v3 ad=2.08p pd=8.52u as=3.52p ps=16.88u w=8u l=0.28u
X277 VSS.t253 XBANK.XSEL.B_P.t5 VSS.t252 VSS.t66 nfet_03v3 ad=1.76p pd=8.88u as=0 ps=0 w=4u l=3.45u
X278 XBANK.XGAIN.XSTART.NODEP.t3 XBANK.XGAIN.XBUF.INP.t4 a_24948_n500.t6 VSS.t59 nfet_03v3 ad=2.2p pd=10.88u as=1.3p ps=5.52u w=5u l=0.28u
X279 XBANK.XFDAC.CTRL_B a_n17500_n24800# VSS.t256 ppolyf_u r_width=2u r_length=20u
X280 a_14628_89200.t2 DIV_P.t8 DIV_N.t0 VSS.t202 nfet_03v3 ad=1.56p pd=6.52u as=2.64p ps=12.88u w=6u l=0.28u
X281 a_38500_n24800# a_35500_n24800# VSS.t108 ppolyf_u r_width=2u r_length=20u
X282 a_n16000_n37702.t4 F_B3.t0 VREFH.t2 VSS.t259 nfet_03v3 ad=3.52p pd=16.88u as=2.08p ps=8.52u w=8u l=0.28u
X283 a_n4252_53500.t2 XBANK.XSEL.B_P.t9 a_n5996_53500.t0 VSS.t30 nfet_03v3 ad=1.3p pd=5.52u as=2.2p ps=10.88u w=5u l=0.28u
X284 a_n5852_53500.t4 XBANK.XSEL.A_N.t7 a_n2796_53500.t2 VSS.t67 nfet_03v3 ad=1.3p pd=5.52u as=2.2p ps=10.88u w=5u l=0.28u
X285 VSS.t97 XBANK.XSEL.A_P.t5 VSS.t96 VSS.t53 nfet_03v3 ad=1.408p pd=7.28u as=0 ps=0 w=3.2u l=4.48u
X286 a_24948_25100.t5 XBANK.XGDAC.CTRL_A VSS.t143 VSS.t142 nfet_03v3 ad=4.4p pd=20.88u as=2.6p ps=10.52u w=10u l=0.28u
X287 a_n28972_12400.t1 XBANK.XFDAC.CTRL_B VSS.t79 VSS.t76 nfet_03v3 ad=2.64p pd=12.88u as=1.56p ps=6.52u w=6u l=0.28u
X288 a_n40400_n37702.t4 F_A3.t0 VREFH.t14 VSS.t107 nfet_03v3 ad=3.52p pd=16.88u as=2.08p ps=8.52u w=8u l=0.28u
X289 VREFL.t4 G_A3B.t1 a_15600_n37702.t0 VSS.t68 nfet_03v3 ad=2.08p pd=8.52u as=3.52p ps=16.88u w=8u l=0.28u
X290 VDD.t2 XREST.OUT_N.t0 VSS.t7 ppolyf_u r_width=2u r_length=7.5u
X291 a_1748_53500.t7 SEL_BUF.t0 VSS.t233 VSS.t17 nfet_03v3 ad=4.4p pd=20.88u as=2.6p ps=10.52u w=10u l=0.28u
X292 VSS.t171 XBANK.XGDAC.CTRL_B a_27028_38000.t2 VSS.t165 nfet_03v3 ad=1.04p pd=4.52u as=1.76p ps=8.88u w=4u l=0.28u
X293 VREFL.t39 G_B3B.t1 a_40000_n37702.t3 VSS.t270 nfet_03v3 ad=2.08p pd=8.52u as=3.52p ps=16.88u w=8u l=0.28u
X294 XBANK.XGDAC.CTRL_A a_14100_n28902# VSS.t83 ppolyf_u r_width=2u r_length=20u
X295 a_3284_89200.t3 a_4960_89000.t9 a_5028_89200.t4 VSS.t265 nfet_03v3 ad=2.64p pd=12.88u as=1.56p ps=6.52u w=6u l=0.28u
X296 DIV_P.t4 DIV_RESET.t0 VSS.t182 VSS.t181 nfet_03v3 ad=0.88p pd=4.88u as=0.52p ps=2.52u w=2u l=0.28u
X297 XREST.OUT_N.t2 a_3600_70348.t3 a_2148_76800.t4 VSS.t36 nfet_03v3 ad=4.4p pd=20.88u as=2.6p ps=10.52u w=10u l=0.28u
X298 VDD.t8 XBANK.XGAIN.XBUF.INP.t0 VSS.t66 ppolyf_u r_width=2u r_length=6.5u
X299 VREFL.t29 F_B0B.t1 a_n25000_n37702.t1 VSS.t240 nfet_03v3 ad=2.08p pd=8.52u as=3.52p ps=16.88u w=8u l=0.28u
X300 VDD.t13 XBANK.XFAST.XBUF.INP.t2 VSS.t53 ppolyf_u r_width=2u r_length=4u
X301 DIV_P.t2 a_4960_89000.t7 a_13028_89200.t3 VSS.t111 nfet_03v3 ad=2.64p pd=12.88u as=1.56p ps=6.52u w=6u l=0.28u
X302 VSS.t134 XBANK.XGDAC.CTRL_A a_24948_n500.t3 VSS.t133 nfet_03v3 ad=2.6p pd=10.52u as=2.6p ps=10.52u w=10u l=0.28u
X303 a_3600_70348.t2 XREST.IN_N.t5 a_2148_67400.t4 VSS.t36 nfet_03v3 ad=4.4p pd=20.88u as=2.6p ps=10.52u w=10u l=0.28u
X304 a_15600_n37702.t3 G_A3.t0 VREFH.t7 VSS.t69 nfet_03v3 ad=3.52p pd=16.88u as=2.08p ps=8.52u w=8u l=0.28u
X305 VDD.t25 a_3284_89200.t4 VSS.t245 ppolyf_u r_width=2u r_length=7.5u
X306 a_2148_67400.t3 REST_BIAS.t0 VSS.t21 VSS.t17 nfet_03v3 ad=5.28p pd=24.88u as=3.12p ps=12.52u w=12u l=0.28u
X307 a_n5852_53500.t10 SEL_A.t0 VSS.t208 VSS.t49 nfet_03v3 ad=2.2p pd=10.88u as=1.3p ps=5.52u w=5u l=0.28u
X308 a_n4252_53500.t4 SEL_B.t2 VSS.t46 VSS.t45 nfet_03v3 ad=1.3p pd=5.52u as=1.3p ps=5.52u w=5u l=0.28u
X309 a_40000_n37702.t2 G_B3.t0 VREFH.t36 VSS.t271 nfet_03v3 ad=3.52p pd=16.88u as=2.08p ps=8.52u w=8u l=0.28u
X310 a_n5996_53500.t3 XBANK.XSEL.B_P.t6 a_n4252_53500.t7 VSS.t57 nfet_03v3 ad=2.2p pd=10.88u as=1.3p ps=5.52u w=5u l=0.28u
X311 XREST.IN_N.t2 a_n2796_53500.t11 a_1748_53500.t2 VSS.t162 nfet_03v3 ad=2.2p pd=10.88u as=1.3p ps=5.52u w=5u l=0.28u
X312 a_24948_37900.t1 XBANK.XGDAC.CTRL_A VSS.t140 VSS.t135 nfet_03v3 ad=2.6p pd=10.52u as=2.6p ps=10.52u w=10u l=0.28u
X313 VSS.t52 XBANK.XGAIN.XBUF.INN.t7 VSS.t51 VSS.t26 nfet_03v3 ad=1.76p pd=8.88u as=0 ps=0 w=4u l=3.45u
X314 a_4628_86600.t5 DIV_BIAS.t6 VSS.t121 VSS.t120 nfet_03v3 ad=2.6p pd=10.52u as=2.6p ps=10.52u w=10u l=0.28u
X315 VSS.t114 XBANK.XFAST.XSTART.NODEN.t6 VSS.t113 VSS.t6 nfet_03v3 ad=1.408p pd=7.28u as=0 ps=0 w=3.2u l=4.48u
X316 XBANK.XFAST.XSTART.NODEN.t3 XBANK.XFAST.XBUF.INN.t4 a_n31052_n500.t2 VSS.t236 nfet_03v3 ad=2.2p pd=10.88u as=1.3p ps=5.52u w=5u l=0.28u
X317 a_4960_89000.t1 DIV_RESET.t2 VSS.t178 VSS.t177 nfet_03v3 ad=0.88p pd=4.88u as=0.52p ps=2.52u w=2u l=0.28u
X318 a_n28972_38000.t0 XBANK.XSEL.A_N.t4 XBANK.XSEL.A_P.t0 VSS.t56 nfet_03v3 ad=1.76p pd=8.88u as=1.76p ps=8.88u w=4u l=0.28u
X319 VSS.t279 XBANK.XGAIN.X2.INP.t5 VSS.t278 VSS.t66 nfet_03v3 ad=1.76p pd=8.88u as=0 ps=0 w=4u l=3.45u
X320 a_n37400_n37702.t1 F_A2B.t0 VREFL.t0 VSS.t1 nfet_03v3 ad=3.52p pd=16.88u as=2.08p ps=8.52u w=8u l=0.28u
X321 a_2148_76800.t3 REST_BIAS.t4 VSS.t18 VSS.t17 nfet_03v3 ad=5.28p pd=24.88u as=3.12p ps=12.52u w=12u l=0.28u
X322 VSS.t275 XBANK.XFAST.X2.INP.t5 VSS.t274 VSS.t53 nfet_03v3 ad=1.408p pd=7.28u as=0 ps=0 w=3.2u l=4.48u
X323 a_n22000_n37702.t4 F_B1B.t0 VREFL.t32 VSS.t223 nfet_03v3 ad=3.52p pd=16.88u as=2.08p ps=8.52u w=8u l=0.28u
X324 VSS.t230 SEL_BUF.t3 a_1748_53500.t4 VSS.t10 nfet_03v3 ad=2.6p pd=10.52u as=4.4p ps=20.88u w=10u l=0.28u
X325 VDD.t5 XBANK.XFAST.X2.INN.t0 VSS.t6 ppolyf_u r_width=2u r_length=4u
X326 XBANK.XFAST.X2.INP.t1 XBANK.XFAST.XSTART.NODEP.t7 a_n31052_12300.t1 VSS.t3 nfet_03v3 ad=2.2p pd=10.88u as=1.3p ps=5.52u w=5u l=0.28u
X327 a_n35900_n28902# a_n34400_n37702.t2 VSS.t198 ppolyf_u r_width=2u r_length=40u
X328 a_1748_53500.t0 a_n5996_53500.t10 XREST.IN_P.t2 VSS.t35 nfet_03v3 ad=1.3p pd=5.52u as=2.2p ps=10.88u w=5u l=0.28u
X329 a_n31052_37900.t1 XBANK.XFAST.XBUF.INP.t9 XBANK.XSEL.A_P.t2 VSS.t2 nfet_03v3 ad=1.3p pd=5.52u as=2.2p ps=10.88u w=5u l=0.28u
X330 XBANK.XSEL.B_N.t2 XBANK.XGAIN.XBUF.INN.t8 a_24948_37900.t5 VSS.t64 nfet_03v3 ad=2.2p pd=10.88u as=1.3p ps=5.52u w=5u l=0.28u
X331 a_27028_25200.t2 XBANK.XGDAC.CTRL_B VSS.t169 VSS.t168 nfet_03v3 ad=1.76p pd=8.88u as=1.04p ps=4.52u w=4u l=0.28u
X332 a_24948_12300.t2 XBANK.XGAIN.XSTART.NODEN.t8 XBANK.XGAIN.X2.INN.t0 VSS.t93 nfet_03v3 ad=1.3p pd=5.52u as=2.2p ps=10.88u w=5u l=0.28u
X333 a_24948_12300.t4 XBANK.XGDAC.CTRL_A VSS.t149 VSS.t135 nfet_03v3 ad=2.6p pd=10.52u as=2.6p ps=10.52u w=10u l=0.28u
X334 VREFH.t13 G_A4.t1 a_12600_n37702.t2 VSS.t104 nfet_03v3 ad=2.08p pd=8.52u as=3.52p ps=16.88u w=8u l=0.28u
X335 a_n28972_38000.t3 XBANK.XSEL.A_P.t4 XBANK.XSEL.A_N.t1 VSS.t158 nfet_03v3 ad=1.76p pd=8.88u as=1.76p ps=8.88u w=4u l=0.28u
X336 a_n31052_n500.t3 XBANK.XFAST.XBUF.INN.t5 XBANK.XFAST.XSTART.NODEN.t4 VSS.t22 nfet_03v3 ad=1.3p pd=5.52u as=2.2p ps=10.88u w=5u l=0.28u
X337 a_37000_n37702.t4 G_B2B.t0 VREFL.t40 VSS.t229 nfet_03v3 ad=3.52p pd=16.88u as=2.08p ps=8.52u w=8u l=0.28u
X338 a_32500_n24800# a_34000_n37702.t2 VSS.t237 ppolyf_u r_width=2u r_length=40u
X339 VREFH.t26 F_A2.t1 a_n37400_n37702.t3 VSS.t0 nfet_03v3 ad=2.08p pd=8.52u as=3.52p ps=16.88u w=8u l=0.28u
X340 VSS.t11 REST_BIAS.t3 a_2148_67400.t0 VSS.t10 nfet_03v3 ad=3.12p pd=12.52u as=5.28p ps=24.88u w=12u l=0.28u
X341 VSS.t131 FAST_KICKN.t0 XBANK.XFAST.XSTART.NODEN.t0 VSS.t130 nfet_03v3 ad=0.44p pd=2.88u as=0.44p ps=2.88u w=1u l=0.28u
X342 VSS.t219 GAIN_KICKP.t0 XBANK.XGAIN.XSTART.NODEP.t4 VSS.t218 nfet_03v3 ad=0.44p pd=2.88u as=0.44p ps=2.88u w=1u l=0.28u
X343 a_n27200_n29600# VREFL.t14 VSS.t158 ppolyf_u r_width=2u r_length=40u
X344 a_28800_n29600# VREFL.t6 VSS.t94 ppolyf_u r_width=2u r_length=40u
X345 VDD.t20 a_2000_70348.t2 VSS.t153 ppolyf_u r_width=2u r_length=7.5u
X346 a_21600_n37702.t1 G_A1B.t0 VREFL.t3 VSS.t32 nfet_03v3 ad=3.52p pd=16.88u as=2.08p ps=8.52u w=8u l=0.28u
X347 VREFH.t38 F_B1.t1 a_n22000_n37702.t1 VSS.t222 nfet_03v3 ad=2.08p pd=8.52u as=3.52p ps=16.88u w=8u l=0.28u
X348 XBANK.XSEL.A_N.t3 XBANK.XFAST.XBUF.INN.t8 a_n31052_37900.t3 VSS.t236 nfet_03v3 ad=2.2p pd=10.88u as=1.3p ps=5.52u w=5u l=0.28u
X349 a_n31052_37900.t5 XBANK.XFDAC.CTRL_A VSS.t284 VSS.t283 nfet_03v3 ad=3.9p pd=15.52u as=3.9p ps=15.52u w=15u l=0.28u
X350 a_24948_37900.t4 XBANK.XGAIN.XBUF.INP.t9 XBANK.XSEL.B_P.t0 VSS.t39 nfet_03v3 ad=1.3p pd=5.52u as=2.2p ps=10.88u w=5u l=0.28u
X351 VSS.t138 XBANK.XGDAC.CTRL_A a_24948_12300.t3 VSS.t137 nfet_03v3 ad=2.6p pd=10.52u as=4.4p ps=20.88u w=10u l=0.28u
R0 G_B4B.n0 G_B4B.t0 113.63
R1 G_B4B.n0 G_B4B.t1 113.603
R2 G_B4B G_B4B.n0 22.3237
R3 G_B3B.n0 G_B3B.t0 113.63
R4 G_B3B.n0 G_B3B.t1 113.603
R5 G_B3B G_B3B.n0 22.3237
R6 G_B2B.n0 G_B2B.t0 113.63
R7 G_B2B.n0 G_B2B.t1 113.603
R8 G_B2B G_B2B.n0 22.3237
R9 G_B1B.n0 G_B1B.t0 113.63
R10 G_B1B.n0 G_B1B.t1 113.603
R11 G_B1B G_B1B.n0 22.3237
R12 G_B0B.n0 G_B0B.t0 113.63
R13 G_B0B.n0 G_B0B.t1 113.603
R14 G_B0B G_B0B.n0 22.3237
R15 G_A0B.n0 G_A0B.t1 113.63
R16 G_A0B.n0 G_A0B.t0 113.603
R17 G_A0B G_A0B.n0 22.3237
R18 G_A1B.n0 G_A1B.t1 113.63
R19 G_A1B.n0 G_A1B.t0 113.603
R20 G_A1B G_A1B.n0 22.3237
R21 G_A2B.n0 G_A2B.t1 113.63
R22 G_A2B.n0 G_A2B.t0 113.603
R23 G_A2B G_A2B.n0 22.3237
R24 G_A3B.n0 G_A3B.t1 113.63
R25 G_A3B.n0 G_A3B.t0 113.603
R26 G_A3B G_A3B.n0 22.3237
R27 G_A4B.n0 G_A4B.t1 113.63
R28 G_A4B.n0 G_A4B.t0 113.603
R29 G_A4B G_A4B.n0 22.3237
R30 G_B4.n0 G_B4.t1 113.63
R31 G_B4.n0 G_B4.t0 113.603
R32 G_B4 G_B4.n0 26.5259
R33 G_B3.n0 G_B3.t1 113.63
R34 G_B3.n0 G_B3.t0 113.603
R35 G_B3 G_B3.n0 26.5259
R36 G_B2.n0 G_B2.t1 113.63
R37 G_B2.n0 G_B2.t0 113.603
R38 G_B2 G_B2.n0 26.5259
R39 G_B1.n0 G_B1.t1 113.63
R40 G_B1.n0 G_B1.t0 113.603
R41 G_B1 G_B1.n0 26.5259
R42 G_B0.n0 G_B0.t1 113.63
R43 G_B0.n0 G_B0.t0 113.603
R44 G_B0 G_B0.n0 26.5259
R45 G_A0.n0 G_A0.t0 113.63
R46 G_A0.n0 G_A0.t1 113.603
R47 G_A0 G_A0.n0 26.5259
R48 G_A1.n0 G_A1.t0 113.63
R49 G_A1.n0 G_A1.t1 113.603
R50 G_A1 G_A1.n0 26.5259
R51 G_A2.n0 G_A2.t0 113.63
R52 G_A2.n0 G_A2.t1 113.603
R53 G_A2 G_A2.n0 26.5259
R54 G_A3.n0 G_A3.t0 113.63
R55 G_A3.n0 G_A3.t1 113.603
R56 G_A3 G_A3.n0 26.5259
R57 G_A4.n0 G_A4.t0 113.63
R58 G_A4.n0 G_A4.t1 113.603
R59 G_A4 G_A4.n0 26.5259
R60 F_B4B.n0 F_B4B.t0 113.63
R61 F_B4B.n0 F_B4B.t1 113.603
R62 F_B4B F_B4B.n0 22.3237
R63 F_B3B.n0 F_B3B.t0 113.63
R64 F_B3B.n0 F_B3B.t1 113.603
R65 F_B3B F_B3B.n0 22.3237
R66 F_B2B.n0 F_B2B.t0 113.63
R67 F_B2B.n0 F_B2B.t1 113.603
R68 F_B2B F_B2B.n0 22.3237
R69 F_B1B.n0 F_B1B.t0 113.63
R70 F_B1B.n0 F_B1B.t1 113.603
R71 F_B1B F_B1B.n0 22.3237
R72 F_B0B.n0 F_B0B.t0 113.63
R73 F_B0B.n0 F_B0B.t1 113.603
R74 F_B0B F_B0B.n0 22.3237
R75 F_A0B.n0 F_A0B.t1 113.63
R76 F_A0B.n0 F_A0B.t0 113.603
R77 F_A0B F_A0B.n0 22.3237
R78 F_A1B.n0 F_A1B.t1 113.63
R79 F_A1B.n0 F_A1B.t0 113.603
R80 F_A1B F_A1B.n0 22.3237
R81 F_A2B.n0 F_A2B.t1 113.63
R82 F_A2B.n0 F_A2B.t0 113.603
R83 F_A2B F_A2B.n0 22.3237
R84 F_A3B.n0 F_A3B.t1 113.63
R85 F_A3B.n0 F_A3B.t0 113.603
R86 F_A3B F_A3B.n0 22.3237
R87 F_A4B.n0 F_A4B.t1 113.63
R88 F_A4B.n0 F_A4B.t0 113.603
R89 F_A4B F_A4B.n0 22.3237
R90 VREFH.n2 VREFH.n0 11.9554
R91 VREFH.n21 VREFH.n19 11.9554
R92 VREFH.n2 VREFH.n1 10.1791
R93 VREFH.n4 VREFH.n3 10.1791
R94 VREFH.n6 VREFH.n5 10.1791
R95 VREFH.n8 VREFH.n7 10.1791
R96 VREFH.n10 VREFH.n9 10.1791
R97 VREFH.n12 VREFH.n11 10.1791
R98 VREFH.n14 VREFH.n13 10.1791
R99 VREFH.n16 VREFH.n15 10.1791
R100 VREFH.n18 VREFH.n17 10.1791
R101 VREFH.n37 VREFH.n36 10.1791
R102 VREFH.n35 VREFH.n34 10.1791
R103 VREFH.n33 VREFH.n32 10.1791
R104 VREFH.n31 VREFH.n30 10.1791
R105 VREFH.n29 VREFH.n28 10.1791
R106 VREFH.n27 VREFH.n26 10.1791
R107 VREFH.n25 VREFH.n24 10.1791
R108 VREFH.n23 VREFH.n22 10.1791
R109 VREFH.n21 VREFH.n20 10.1791
R110 VREFH VREFH.n18 8.17155
R111 VREFH VREFH.n37 6.98734
R112 VREFH.n29 VREFH.n27 3.78997
R113 VREFH.n10 VREFH.n8 3.78997
R114 VREFH.n23 VREFH.n21 1.77682
R115 VREFH.n25 VREFH.n23 1.77682
R116 VREFH.n27 VREFH.n25 1.77682
R117 VREFH.n31 VREFH.n29 1.77682
R118 VREFH.n33 VREFH.n31 1.77682
R119 VREFH.n35 VREFH.n33 1.77682
R120 VREFH.n37 VREFH.n35 1.77682
R121 VREFH.n18 VREFH.n16 1.77682
R122 VREFH.n16 VREFH.n14 1.77682
R123 VREFH.n14 VREFH.n12 1.77682
R124 VREFH.n12 VREFH.n10 1.77682
R125 VREFH.n8 VREFH.n6 1.77682
R126 VREFH.n6 VREFH.n4 1.77682
R127 VREFH.n4 VREFH.n2 1.77682
R128 VREFH.n0 VREFH.t30 0.20525
R129 VREFH.n0 VREFH.t31 0.20525
R130 VREFH.n1 VREFH.t37 0.20525
R131 VREFH.n1 VREFH.t36 0.20525
R132 VREFH.n3 VREFH.t22 0.20525
R133 VREFH.n3 VREFH.t23 0.20525
R134 VREFH.n5 VREFH.t28 0.20525
R135 VREFH.n5 VREFH.t29 0.20525
R136 VREFH.n7 VREFH.t21 0.20525
R137 VREFH.n7 VREFH.t20 0.20525
R138 VREFH.n9 VREFH.t10 0.20525
R139 VREFH.n9 VREFH.t11 0.20525
R140 VREFH.n11 VREFH.t8 0.20525
R141 VREFH.n11 VREFH.t9 0.20525
R142 VREFH.n13 VREFH.t17 0.20525
R143 VREFH.n13 VREFH.t18 0.20525
R144 VREFH.n15 VREFH.t6 0.20525
R145 VREFH.n15 VREFH.t7 0.20525
R146 VREFH.n17 VREFH.t13 0.20525
R147 VREFH.n17 VREFH.t12 0.20525
R148 VREFH.n36 VREFH.t4 0.20525
R149 VREFH.n36 VREFH.t35 0.20525
R150 VREFH.n34 VREFH.t1 0.20525
R151 VREFH.n34 VREFH.t2 0.20525
R152 VREFH.n32 VREFH.t0 0.20525
R153 VREFH.n32 VREFH.t19 0.20525
R154 VREFH.n30 VREFH.t38 0.20525
R155 VREFH.n30 VREFH.t39 0.20525
R156 VREFH.n28 VREFH.t32 0.20525
R157 VREFH.n28 VREFH.t5 0.20525
R158 VREFH.n26 VREFH.t34 0.20525
R159 VREFH.n26 VREFH.t3 0.20525
R160 VREFH.n24 VREFH.t33 0.20525
R161 VREFH.n24 VREFH.t27 0.20525
R162 VREFH.n22 VREFH.t26 0.20525
R163 VREFH.n22 VREFH.t15 0.20525
R164 VREFH.n20 VREFH.t16 0.20525
R165 VREFH.n20 VREFH.t14 0.20525
R166 VREFH.n19 VREFH.t25 0.20525
R167 VREFH.n19 VREFH.t24 0.20525
R168 F_B4.n0 F_B4.t1 113.63
R169 F_B4.n0 F_B4.t0 113.603
R170 F_B4 F_B4.n0 26.5259
R171 F_B3.n0 F_B3.t1 113.63
R172 F_B3.n0 F_B3.t0 113.603
R173 F_B3 F_B3.n0 26.5259
R174 F_B2.n0 F_B2.t1 113.63
R175 F_B2.n0 F_B2.t0 113.603
R176 F_B2 F_B2.n0 26.5259
R177 F_B1.n0 F_B1.t1 113.63
R178 F_B1.n0 F_B1.t0 113.603
R179 F_B1 F_B1.n0 26.5259
R180 F_B0.n0 F_B0.t1 113.63
R181 F_B0.n0 F_B0.t0 113.603
R182 F_B0 F_B0.n0 26.5259
R183 F_A0.n0 F_A0.t0 113.63
R184 F_A0.n0 F_A0.t1 113.603
R185 F_A0 F_A0.n0 26.5259
R186 F_A1.n0 F_A1.t0 113.63
R187 F_A1.n0 F_A1.t1 113.603
R188 F_A1 F_A1.n0 26.5259
R189 F_A2.n0 F_A2.t0 113.63
R190 F_A2.n0 F_A2.t1 113.603
R191 F_A2 F_A2.n0 26.5259
R192 F_A3.n0 F_A3.t0 113.63
R193 F_A3.n0 F_A3.t1 113.603
R194 F_A3 F_A3.n0 26.5259
R195 F_A4.n0 F_A4.t0 113.63
R196 F_A4.n0 F_A4.t1 113.603
R197 F_A4 F_A4.n0 26.5259
R198 VREFL.n30 VREFL.t13 32.3061
R199 VREFL.n31 VREFL.t14 32.3061
R200 VREFL.n10 VREFL.t17 32.3061
R201 VREFL.n9 VREFL.t6 32.3061
R202 VREFL.n2 VREFL.n0 11.9554
R203 VREFL.n23 VREFL.n21 11.9554
R204 VREFL.n2 VREFL.n1 10.1791
R205 VREFL.n4 VREFL.n3 10.1791
R206 VREFL.n6 VREFL.n5 10.1791
R207 VREFL.n8 VREFL.n7 10.1791
R208 VREFL.n12 VREFL.n11 10.1791
R209 VREFL.n14 VREFL.n13 10.1791
R210 VREFL.n16 VREFL.n15 10.1791
R211 VREFL.n18 VREFL.n17 10.1791
R212 VREFL.n20 VREFL.n19 10.1791
R213 VREFL.n41 VREFL.n40 10.1791
R214 VREFL.n39 VREFL.n38 10.1791
R215 VREFL.n37 VREFL.n36 10.1791
R216 VREFL.n35 VREFL.n34 10.1791
R217 VREFL.n33 VREFL.n32 10.1791
R218 VREFL.n29 VREFL.n28 10.1791
R219 VREFL.n27 VREFL.n26 10.1791
R220 VREFL.n25 VREFL.n24 10.1791
R221 VREFL.n23 VREFL.n22 10.1791
R222 VREFL VREFL.n20 8.17155
R223 VREFL VREFL.n41 6.98734
R224 VREFL.n25 VREFL.n23 1.77682
R225 VREFL.n27 VREFL.n25 1.77682
R226 VREFL.n29 VREFL.n27 1.77682
R227 VREFL.n35 VREFL.n33 1.77682
R228 VREFL.n37 VREFL.n35 1.77682
R229 VREFL.n39 VREFL.n37 1.77682
R230 VREFL.n41 VREFL.n39 1.77682
R231 VREFL.n20 VREFL.n18 1.77682
R232 VREFL.n18 VREFL.n16 1.77682
R233 VREFL.n16 VREFL.n14 1.77682
R234 VREFL.n14 VREFL.n12 1.77682
R235 VREFL.n8 VREFL.n6 1.77682
R236 VREFL.n6 VREFL.n4 1.77682
R237 VREFL.n4 VREFL.n2 1.77682
R238 VREFL.n30 VREFL.n29 1.30313
R239 VREFL.n33 VREFL.n31 1.30313
R240 VREFL.n12 VREFL.n10 1.30313
R241 VREFL.n9 VREFL.n8 1.30313
R242 VREFL.n31 VREFL.n30 1.18471
R243 VREFL.n10 VREFL.n9 1.18471
R244 VREFL.n0 VREFL.t30 0.20525
R245 VREFL.n0 VREFL.t31 0.20525
R246 VREFL.n1 VREFL.t39 0.20525
R247 VREFL.n1 VREFL.t38 0.20525
R248 VREFL.n3 VREFL.t41 0.20525
R249 VREFL.n3 VREFL.t40 0.20525
R250 VREFL.n5 VREFL.t8 0.20525
R251 VREFL.n5 VREFL.t7 0.20525
R252 VREFL.n7 VREFL.t20 0.20525
R253 VREFL.n7 VREFL.t21 0.20525
R254 VREFL.n11 VREFL.t27 0.20525
R255 VREFL.n11 VREFL.t26 0.20525
R256 VREFL.n13 VREFL.t2 0.20525
R257 VREFL.n13 VREFL.t3 0.20525
R258 VREFL.n15 VREFL.t16 0.20525
R259 VREFL.n15 VREFL.t15 0.20525
R260 VREFL.n17 VREFL.t4 0.20525
R261 VREFL.n17 VREFL.t5 0.20525
R262 VREFL.n19 VREFL.t9 0.20525
R263 VREFL.n19 VREFL.t10 0.20525
R264 VREFL.n40 VREFL.t19 0.20525
R265 VREFL.n40 VREFL.t18 0.20525
R266 VREFL.n38 VREFL.t35 0.20525
R267 VREFL.n38 VREFL.t34 0.20525
R268 VREFL.n36 VREFL.t23 0.20525
R269 VREFL.n36 VREFL.t22 0.20525
R270 VREFL.n34 VREFL.t33 0.20525
R271 VREFL.n34 VREFL.t32 0.20525
R272 VREFL.n32 VREFL.t29 0.20525
R273 VREFL.n32 VREFL.t28 0.20525
R274 VREFL.n28 VREFL.t24 0.20525
R275 VREFL.n28 VREFL.t25 0.20525
R276 VREFL.n26 VREFL.t43 0.20525
R277 VREFL.n26 VREFL.t42 0.20525
R278 VREFL.n24 VREFL.t1 0.20525
R279 VREFL.n24 VREFL.t0 0.20525
R280 VREFL.n22 VREFL.t12 0.20525
R281 VREFL.n22 VREFL.t11 0.20525
R282 VREFL.n21 VREFL.t37 0.20525
R283 VREFL.n21 VREFL.t36 0.20525
R284 GAIN_KICKN GAIN_KICKN.t0 78.5823
R285 GAIN_KICKP GAIN_KICKP.t0 78.5823
R286 FAST_KICKN FAST_KICKN.t0 78.5823
R287 FAST_KICKP FAST_KICKP.t0 78.5823
R288 SEL_B.n0 SEL_B.t0 74.5242
R289 SEL_B.n3 SEL_B.t3 74.5242
R290 SEL_B.n1 SEL_B.t1 70.0675
R291 SEL_B.n2 SEL_B.t2 70.0675
R292 SEL_B SEL_B.n4 18.2966
R293 SEL_B.n2 SEL_B.n1 11.6805
R294 SEL_B.n4 SEL_B.n0 7.10487
R295 SEL_B.n4 SEL_B.n3 7.10487
R296 SEL_B.n1 SEL_B.n0 4.42851
R297 SEL_B.n3 SEL_B.n2 4.42851
R298 SEL_A.n0 SEL_A.t0 74.5242
R299 SEL_A.n3 SEL_A.t3 74.5242
R300 SEL_A.n1 SEL_A.t1 70.0675
R301 SEL_A.n2 SEL_A.t2 70.0675
R302 SEL_A SEL_A.n4 16.6979
R303 SEL_A.n2 SEL_A.n1 11.6805
R304 SEL_A.n4 SEL_A.n0 7.10487
R305 SEL_A.n4 SEL_A.n3 7.10487
R306 SEL_A.n1 SEL_A.n0 4.42851
R307 SEL_A.n3 SEL_A.n2 4.42851
R308 SEL_BUF.n0 SEL_BUF.t0 139.702
R309 SEL_BUF.n3 SEL_BUF.t3 139.702
R310 SEL_BUF.n1 SEL_BUF.t1 135.246
R311 SEL_BUF.n2 SEL_BUF.t2 135.246
R312 SEL_BUF SEL_BUF.n4 14.7439
R313 SEL_BUF.n2 SEL_BUF.n1 11.6805
R314 SEL_BUF.n4 SEL_BUF.n0 7.10487
R315 SEL_BUF.n4 SEL_BUF.n3 7.10487
R316 SEL_BUF.n1 SEL_BUF.n0 4.42851
R317 SEL_BUF.n3 SEL_BUF.n2 4.42851
R318 REST_BIAS.n8 REST_BIAS.t3 165.774
R319 REST_BIAS.n5 REST_BIAS.t0 165.774
R320 REST_BIAS.n0 REST_BIAS.t4 165.774
R321 REST_BIAS.n3 REST_BIAS.t7 165.774
R322 REST_BIAS.n6 REST_BIAS.t1 161.317
R323 REST_BIAS.n7 REST_BIAS.t2 161.317
R324 REST_BIAS.n1 REST_BIAS.t5 161.317
R325 REST_BIAS.n2 REST_BIAS.t6 161.317
R326 REST_BIAS.n10 REST_BIAS.n4 19.0663
R327 REST_BIAS.n10 REST_BIAS.n9 13.5005
R328 REST_BIAS.n7 REST_BIAS.n6 11.6805
R329 REST_BIAS.n2 REST_BIAS.n1 11.6805
R330 REST_BIAS.n9 REST_BIAS.n5 7.10487
R331 REST_BIAS.n9 REST_BIAS.n8 7.10487
R332 REST_BIAS.n4 REST_BIAS.n0 7.10487
R333 REST_BIAS.n4 REST_BIAS.n3 7.10487
R334 REST_BIAS.n6 REST_BIAS.n5 4.42851
R335 REST_BIAS.n8 REST_BIAS.n7 4.42851
R336 REST_BIAS.n1 REST_BIAS.n0 4.42851
R337 REST_BIAS.n3 REST_BIAS.n2 4.42851
R338 REST_BIAS REST_BIAS.n10 0.250763
R339 DIV_RESET.n1 DIV_RESET.t2 35.4171
R340 DIV_RESET.n0 DIV_RESET.t1 35.4171
R341 DIV_RESET.n1 DIV_RESET.t3 35.3883
R342 DIV_RESET.n0 DIV_RESET.t0 35.3883
R343 DIV_RESET.n2 DIV_RESET.n1 25.8112
R344 DIV_RESET.n2 DIV_RESET.n0 25.8112
R345 DIV_RESET DIV_RESET.n2 0.259447
R346 DIV_BIAS.n3 DIV_BIAS.t3 139.702
R347 DIV_BIAS.n0 DIV_BIAS.t0 139.702
R348 DIV_BIAS.n5 DIV_BIAS.t4 139.702
R349 DIV_BIAS.n8 DIV_BIAS.t7 139.702
R350 DIV_BIAS.n1 DIV_BIAS.t1 135.246
R351 DIV_BIAS.n2 DIV_BIAS.t2 135.246
R352 DIV_BIAS.n6 DIV_BIAS.t5 135.246
R353 DIV_BIAS.n7 DIV_BIAS.t6 135.246
R354 DIV_BIAS.n10 DIV_BIAS.n4 19.1847
R355 DIV_BIAS.n10 DIV_BIAS.n9 13.5005
R356 DIV_BIAS.n2 DIV_BIAS.n1 11.6805
R357 DIV_BIAS.n7 DIV_BIAS.n6 11.6805
R358 DIV_BIAS.n4 DIV_BIAS.n0 7.10487
R359 DIV_BIAS.n4 DIV_BIAS.n3 7.10487
R360 DIV_BIAS.n9 DIV_BIAS.n5 7.10487
R361 DIV_BIAS.n9 DIV_BIAS.n8 7.10487
R362 DIV_BIAS.n1 DIV_BIAS.n0 4.42851
R363 DIV_BIAS.n3 DIV_BIAS.n2 4.42851
R364 DIV_BIAS.n6 DIV_BIAS.n5 4.42851
R365 DIV_BIAS.n8 DIV_BIAS.n7 4.42851
R366 DIV_BIAS.n11 DIV_BIAS.n10 1.32326
R367 DIV_BIAS.n11 DIV_BIAS 0.1505
R368 DIV_BIAS DIV_BIAS.n11 0.0893158
R369 DIV_N.n2 DIV_N.t5 87.5461
R370 DIV_N.n2 DIV_N.t6 87.5461
R371 DIV_N.n1 DIV_N.t7 87.5461
R372 DIV_N.n1 DIV_N.t8 87.5461
R373 DIV_N.n9 DIV_N.n1 31.3365
R374 DIV_N.n3 DIV_N.n2 26.3217
R375 DIV_N DIV_N.t4 12.48
R376 DIV_N.n0 DIV_N.t3 5.96544
R377 DIV_N.n0 DIV_N.t1 5.9622
R378 DIV_N.n6 DIV_N.t2 5.87051
R379 DIV_N.n5 DIV_N.t0 5.87051
R380 DIV_N.n5 DIV_N.n4 4.5005
R381 DIV_N.n7 DIV_N.n6 4.5005
R382 DIV_N.n9 DIV_N.n0 2.56391
R383 DIV_N DIV_N.n9 0.7305
R384 DIV_N.n8 DIV_N.n3 0.419
R385 DIV_N.n9 DIV_N.n8 0.2415
R386 DIV_N.n6 DIV_N.n5 0.189974
R387 DIV_N.n7 DIV_N.n4 0.1605
R388 DIV_N.n8 DIV_N.n7 0.0795
R389 DIV_N.n4 DIV_N.n3 0.0740593
R390 DIV_P.n0 DIV_P.t7 87.5461
R391 DIV_P.n0 DIV_P.t8 87.5461
R392 DIV_P.n8 DIV_P.t9 87.5461
R393 DIV_P.n8 DIV_P.t10 87.5461
R394 DIV_P.n10 DIV_P.n8 38.3766
R395 DIV_P.n1 DIV_P.n0 35.3132
R396 DIV_P DIV_P.t0 12.48
R397 DIV_P.n2 DIV_P.t3 7.21035
R398 DIV_P.n2 DIV_P.t4 7.20745
R399 DIV_P.n9 DIV_P.t1 5.96544
R400 DIV_P.n9 DIV_P.t2 5.9622
R401 DIV_P.n7 DIV_P.n2 5.94824
R402 DIV_P.n4 DIV_P.t5 5.87051
R403 DIV_P.n5 DIV_P.t6 5.87051
R404 DIV_P.n6 DIV_P.n5 4.5005
R405 DIV_P.n4 DIV_P.n3 4.5005
R406 DIV_P.n10 DIV_P.n9 2.56391
R407 DIV_P DIV_P.n10 0.7305
R408 DIV_P.n7 DIV_P.n1 0.419
R409 DIV_P.n10 DIV_P.n7 0.2415
R410 DIV_P.n5 DIV_P.n4 0.189974
R411 DIV_P.n6 DIV_P.n3 0.1605
R412 DIV_P.n7 DIV_P.n6 0.0795
R413 DIV_P.n3 DIV_P.n1 0.0405
R414 VDD VDD.n6 23.3752
R415 VDD.n8 VDD.t23 22.412
R416 VDD.n19 VDD.t25 22.0211
R417 VDD.n7 VDD.t7 21.9835
R418 VDD.n18 VDD.t11 21.7356
R419 VDD.n17 VDD.t20 21.7356
R420 VDD.n8 VDD.t15 21.612
R421 VDD.n7 VDD.t27 21.5835
R422 VDD.n15 VDD.t22 21.4659
R423 VDD.n15 VDD.t6 21.4659
R424 VDD.n12 VDD.t16 21.4659
R425 VDD.n12 VDD.t8 21.4659
R426 VDD.n11 VDD.t26 21.4659
R427 VDD.n11 VDD.t12 21.4659
R428 VDD.n10 VDD.t24 21.4659
R429 VDD.n10 VDD.t21 21.4659
R430 VDD.n5 VDD.t9 21.4659
R431 VDD.n5 VDD.t10 21.4659
R432 VDD.n2 VDD.t3 21.4659
R433 VDD.n2 VDD.t13 21.4659
R434 VDD.n1 VDD.t0 21.4659
R435 VDD.n1 VDD.t14 21.4659
R436 VDD.n0 VDD.t5 21.4659
R437 VDD.n0 VDD.t19 21.4659
R438 VDD.n18 VDD.t2 21.38
R439 VDD.n17 VDD.t1 21.38
R440 VDD.n19 VDD.t17 21.31
R441 VDD.n21 VDD.t18 21.31
R442 VDD.n20 VDD.t4 21.31
R443 VDD.n24 VDD.n16 20.0331
R444 VDD.n13 VDD.n11 16.9789
R445 VDD.n3 VDD.n1 16.9789
R446 VDD.n16 VDD.n15 16.9331
R447 VDD.n6 VDD.n5 16.9331
R448 VDD.n13 VDD.n12 9.48997
R449 VDD.n3 VDD.n2 9.48997
R450 VDD.n14 VDD.n10 9.43668
R451 VDD.n4 VDD.n0 9.43668
R452 VDD.n14 VDD.n13 7.48471
R453 VDD.n4 VDD.n3 7.48471
R454 VDD.n22 VDD.n21 1.3169
R455 VDD.n25 VDD.n9 0.926816
R456 VDD.n20 VDD.n19 0.788589
R457 VDD.n9 VDD.n7 0.7505
R458 VDD VDD.n25 0.564434
R459 VDD.n23 VDD.n22 0.3765
R460 VDD.n24 VDD.n23 0.3729
R461 VDD.n25 VDD.n24 0.343526
R462 VDD.n9 VDD.n8 0.1505
R463 VDD.n21 VDD.n20 0.1285
R464 VDD.n22 VDD.n18 0.111611
R465 VDD.n23 VDD.n17 0.111611
R466 VDD.n16 VDD.n14 0.0305
R467 VDD.n6 VDD.n4 0.0305
R468 VSS.n1102 VSS.n1101 87.492
R469 VSS.n976 VSS.n88 70.0005
R470 VSS.n976 VSS.n75 70.0005
R471 VSS.n990 VSS.n75 70.0005
R472 VSS.n990 VSS.n72 70.0005
R473 VSS.n994 VSS.n72 70.0005
R474 VSS.n994 VSS.n71 70.0005
R475 VSS.n478 VSS.n71 70.0005
R476 VSS.n816 VSS.n478 70.0005
R477 VSS.n816 VSS.n477 70.0005
R478 VSS.n811 VSS.n477 70.0005
R479 VSS.n811 VSS.n434 70.0005
R480 VSS.n808 VSS.n434 70.0005
R481 VSS.n808 VSS.n480 70.0005
R482 VSS.n536 VSS.n480 70.0005
R483 VSS.n620 VSS.n536 70.0005
R484 VSS.n620 VSS.n533 70.0005
R485 VSS.n615 VSS.n533 70.0005
R486 VSS.n615 VSS.n538 70.0005
R487 VSS.n603 VSS.n538 70.0005
R488 VSS.n603 VSS.n548 70.0005
R489 VSS.n589 VSS.n587 70.0005
R490 VSS.n585 VSS.n554 70.0005
R491 VSS.n581 VSS.n579 70.0005
R492 VSS.n577 VSS.n556 70.0005
R493 VSS.n573 VSS.n571 70.0005
R494 VSS.n569 VSS.n558 70.0005
R495 VSS.n565 VSS.n563 70.0005
R496 VSS.n563 VSS.n562 70.0005
R497 VSS.n940 VSS.n87 70.0005
R498 VSS.n935 VSS.n87 70.0005
R499 VSS.n935 VSS.n76 70.0005
R500 VSS.n932 VSS.n76 70.0005
R501 VSS.n932 VSS.n70 70.0005
R502 VSS.n929 VSS.n70 70.0005
R503 VSS.n929 VSS.n102 70.0005
R504 VSS.n475 VSS.n102 70.0005
R505 VSS.n665 VSS.n475 70.0005
R506 VSS.n666 VSS.n665 70.0005
R507 VSS.n666 VSS.n433 70.0005
R508 VSS.n482 VSS.n433 70.0005
R509 VSS.n671 VSS.n482 70.0005
R510 VSS.n671 VSS.n529 70.0005
R511 VSS.n622 VSS.n529 70.0005
R512 VSS.n622 VSS.n531 70.0005
R513 VSS.n609 VSS.n531 70.0005
R514 VSS.n609 VSS.n540 70.0005
R515 VSS.n605 VSS.n540 70.0005
R516 VSS.n605 VSS.n542 70.0005
R517 VSS.n945 VSS.n944 70.0005
R518 VSS.n949 VSS.n948 70.0005
R519 VSS.n953 VSS.n952 70.0005
R520 VSS.n957 VSS.n956 70.0005
R521 VSS.n961 VSS.n960 70.0005
R522 VSS.n965 VSS.n964 70.0005
R523 VSS.n969 VSS.n100 70.0005
R524 VSS.n972 VSS.n90 70.0005
R525 VSS.n1571 VSS.n1369 70.0005
R526 VSS.n1578 VSS.n1369 70.0005
R527 VSS.n1578 VSS.n1367 70.0005
R528 VSS.n1582 VSS.n1367 70.0005
R529 VSS.n1582 VSS.n1360 70.0005
R530 VSS.n1589 VSS.n1360 70.0005
R531 VSS.n1589 VSS.n1357 70.0005
R532 VSS.n1593 VSS.n1357 70.0005
R533 VSS.n1593 VSS.n1356 70.0005
R534 VSS.n1511 VSS.n1356 70.0005
R535 VSS.n1511 VSS.n1300 70.0005
R536 VSS.n1515 VSS.n1300 70.0005
R537 VSS.n1515 VSS.n1490 70.0005
R538 VSS.n1508 VSS.n1490 70.0005
R539 VSS.n1508 VSS.n1507 70.0005
R540 VSS.n1507 VSS.n1506 70.0005
R541 VSS.n1506 VSS.n1492 70.0005
R542 VSS.n1492 VSS.n1145 70.0005
R543 VSS.n1744 VSS.n1145 70.0005
R544 VSS.n1744 VSS.n1105 70.0005
R545 VSS.n1115 VSS.n4 70.0005
R546 VSS.n1117 VSS.n1113 70.0005
R547 VSS.n1121 VSS.n1113 70.0005
R548 VSS.n1124 VSS.n1123 70.0005
R549 VSS.n1126 VSS.n1124 70.0005
R550 VSS.n1130 VSS.n1110 70.0005
R551 VSS.n1133 VSS.n1132 70.0005
R552 VSS.n1137 VSS.n1107 70.0005
R553 VSS.n1141 VSS.n1139 70.0005
R554 VSS.n1373 VSS.n1372 70.0005
R555 VSS.n1372 VSS.n1371 70.0005
R556 VSS.n1535 VSS.n1371 70.0005
R557 VSS.n1535 VSS.n1365 70.0005
R558 VSS.n1365 VSS.n1364 70.0005
R559 VSS.n1364 VSS.n1363 70.0005
R560 VSS.n1528 VSS.n1363 70.0005
R561 VSS.n1528 VSS.n1354 70.0005
R562 VSS.n1524 VSS.n1354 70.0005
R563 VSS.n1524 VSS.n1521 70.0005
R564 VSS.n1521 VSS.n1299 70.0005
R565 VSS.n1517 VSS.n1299 70.0005
R566 VSS.n1517 VSS.n1388 70.0005
R567 VSS.n1501 VSS.n1388 70.0005
R568 VSS.n1501 VSS.n1496 70.0005
R569 VSS.n1505 VSS.n1496 70.0005
R570 VSS.n1505 VSS.n1495 70.0005
R571 VSS.n1498 VSS.n1495 70.0005
R572 VSS.n1498 VSS.n1149 70.0005
R573 VSS.n1149 VSS.n5 70.0005
R574 VSS.n1544 VSS.n1543 70.0005
R575 VSS.n1548 VSS.n1384 70.0005
R576 VSS.n1551 VSS.n1550 70.0005
R577 VSS.n1555 VSS.n1381 70.0005
R578 VSS.n1558 VSS.n1557 70.0005
R579 VSS.n1562 VSS.n1378 70.0005
R580 VSS.n1565 VSS.n1564 70.0005
R581 VSS.n1567 VSS.n1375 70.0005
R582 VSS.n709 VSS.n673 59.5005
R583 VSS.n135 VSS.n109 59.5005
R584 VSS.n1448 VSS.n1183 59.5005
R585 VSS.n1336 VSS.n1232 59.5005
R586 VSS.n743 VSS.n710 59.5005
R587 VSS.n136 VSS.n118 59.5005
R588 VSS.n1482 VSS.n1184 59.5005
R589 VSS.n1620 VSS.n1233 59.5005
R590 VSS.n776 VSS.n744 59.5005
R591 VSS.n900 VSS.n104 59.5005
R592 VSS.n1709 VSS.n1185 59.5005
R593 VSS.n1685 VSS.n1234 59.5005
R594 VSS.n797 VSS.n492 59.5005
R595 VSS.n923 VSS.n123 59.5005
R596 VSS.n1729 VSS.n1175 59.5005
R597 VSS.n1687 VSS.n1226 59.5005
R598 VSS.n256 VSS.n186 59.5005
R599 VSS.n375 VSS.n154 59.5005
R600 VSS.n844 VSS.n135 52.5005
R601 VSS.n844 VSS.n423 52.5005
R602 VSS.n848 VSS.n423 52.5005
R603 VSS.n848 VSS.n409 52.5005
R604 VSS.n435 VSS.n409 52.5005
R605 VSS.n705 VSS.n435 52.5005
R606 VSS.n705 VSS.n489 52.5005
R607 VSS.n709 VSS.n489 52.5005
R608 VSS.n685 VSS.n508 52.5005
R609 VSS.n691 VSS.n690 52.5005
R610 VSS.n695 VSS.n694 52.5005
R611 VSS.n701 VSS.n700 52.5005
R612 VSS.n474 VSS.n133 52.5005
R613 VSS.n474 VSS.n421 52.5005
R614 VSS.n442 VSS.n421 52.5005
R615 VSS.n442 VSS.n406 52.5005
R616 VSS.n432 VSS.n406 52.5005
R617 VSS.n680 VSS.n432 52.5005
R618 VSS.n680 VSS.n488 52.5005
R619 VSS.n528 VSS.n488 52.5005
R620 VSS.n455 VSS.n454 52.5005
R621 VSS.n459 VSS.n458 52.5005
R622 VSS.n463 VSS.n462 52.5005
R623 VSS.n465 VSS.n109 52.5005
R624 VSS.n1626 VSS.n1232 52.5005
R625 VSS.n1626 VSS.n1222 52.5005
R626 VSS.n1630 VSS.n1222 52.5005
R627 VSS.n1630 VSS.n1211 52.5005
R628 VSS.n1301 VSS.n1211 52.5005
R629 VSS.n1301 VSS.n1196 52.5005
R630 VSS.n1454 VSS.n1196 52.5005
R631 VSS.n1454 VSS.n1183 52.5005
R632 VSS.n1432 VSS.n1164 52.5005
R633 VSS.n1436 VSS.n1435 52.5005
R634 VSS.n1440 VSS.n1439 52.5005
R635 VSS.n1446 VSS.n1445 52.5005
R636 VSS.n1353 VSS.n1230 52.5005
R637 VSS.n1353 VSS.n1220 52.5005
R638 VSS.n1307 VSS.n1220 52.5005
R639 VSS.n1307 VSS.n1207 52.5005
R640 VSS.n1298 VSS.n1207 52.5005
R641 VSS.n1298 VSS.n1194 52.5005
R642 VSS.n1418 VSS.n1194 52.5005
R643 VSS.n1418 VSS.n1182 52.5005
R644 VSS.n1324 VSS.n1314 52.5005
R645 VSS.n1327 VSS.n1326 52.5005
R646 VSS.n1333 VSS.n1311 52.5005
R647 VSS.n1336 VSS.n1335 52.5005
R648 VSS.n842 VSS.n136 52.5005
R649 VSS.n842 VSS.n424 52.5005
R650 VSS.n850 VSS.n424 52.5005
R651 VSS.n850 VSS.n410 52.5005
R652 VSS.n854 VSS.n410 52.5005
R653 VSS.n854 VSS.n436 52.5005
R654 VSS.n490 VSS.n436 52.5005
R655 VSS.n743 VSS.n490 52.5005
R656 VSS.n722 VSS.n510 52.5005
R657 VSS.n728 VSS.n727 52.5005
R658 VSS.n732 VSS.n731 52.5005
R659 VSS.n738 VSS.n737 52.5005
R660 VSS.n473 VSS.n132 52.5005
R661 VSS.n473 VSS.n420 52.5005
R662 VSS.n441 VSS.n420 52.5005
R663 VSS.n441 VSS.n405 52.5005
R664 VSS.n431 VSS.n405 52.5005
R665 VSS.n717 VSS.n431 52.5005
R666 VSS.n717 VSS.n487 52.5005
R667 VSS.n527 VSS.n487 52.5005
R668 VSS.n827 VSS.n826 52.5005
R669 VSS.n831 VSS.n830 52.5005
R670 VSS.n835 VSS.n834 52.5005
R671 VSS.n837 VSS.n118 52.5005
R672 VSS.n1624 VSS.n1233 52.5005
R673 VSS.n1624 VSS.n1223 52.5005
R674 VSS.n1632 VSS.n1223 52.5005
R675 VSS.n1632 VSS.n1212 52.5005
R676 VSS.n1636 VSS.n1212 52.5005
R677 VSS.n1636 VSS.n1197 52.5005
R678 VSS.n1486 VSS.n1197 52.5005
R679 VSS.n1486 VSS.n1184 52.5005
R680 VSS.n1466 VSS.n1166 52.5005
R681 VSS.n1470 VSS.n1469 52.5005
R682 VSS.n1474 VSS.n1473 52.5005
R683 VSS.n1480 VSS.n1479 52.5005
R684 VSS.n1352 VSS.n1229 52.5005
R685 VSS.n1352 VSS.n1219 52.5005
R686 VSS.n1306 VSS.n1219 52.5005
R687 VSS.n1306 VSS.n1206 52.5005
R688 VSS.n1297 VSS.n1206 52.5005
R689 VSS.n1297 VSS.n1193 52.5005
R690 VSS.n1417 VSS.n1193 52.5005
R691 VSS.n1417 VSS.n1181 52.5005
R692 VSS.n1608 VSS.n1598 52.5005
R693 VSS.n1611 VSS.n1610 52.5005
R694 VSS.n1617 VSS.n1595 52.5005
R695 VSS.n1620 VSS.n1619 52.5005
R696 VSS.n900 VSS.n137 52.5005
R697 VSS.n861 VSS.n137 52.5005
R698 VSS.n861 VSS.n425 52.5005
R699 VSS.n425 VSS.n411 52.5005
R700 VSS.n856 VSS.n411 52.5005
R701 VSS.n856 VSS.n427 52.5005
R702 VSS.n491 VSS.n427 52.5005
R703 VSS.n776 VSS.n491 52.5005
R704 VSS.n755 VSS.n503 52.5005
R705 VSS.n761 VSS.n760 52.5005
R706 VSS.n765 VSS.n764 52.5005
R707 VSS.n771 VSS.n770 52.5005
R708 VSS.n472 VSS.n131 52.5005
R709 VSS.n472 VSS.n419 52.5005
R710 VSS.n440 VSS.n419 52.5005
R711 VSS.n440 VSS.n404 52.5005
R712 VSS.n430 VSS.n404 52.5005
R713 VSS.n750 VSS.n430 52.5005
R714 VSS.n750 VSS.n486 52.5005
R715 VSS.n526 VSS.n486 52.5005
R716 VSS.n886 VSS.n885 52.5005
R717 VSS.n890 VSS.n889 52.5005
R718 VSS.n894 VSS.n893 52.5005
R719 VSS.n896 VSS.n104 52.5005
R720 VSS.n1685 VSS.n1215 52.5005
R721 VSS.n1693 VSS.n1215 52.5005
R722 VSS.n1693 VSS.n1213 52.5005
R723 VSS.n1697 VSS.n1213 52.5005
R724 VSS.n1697 VSS.n1189 52.5005
R725 VSS.n1705 VSS.n1189 52.5005
R726 VSS.n1705 VSS.n1186 52.5005
R727 VSS.n1709 VSS.n1186 52.5005
R728 VSS.n1405 VSS.n1159 52.5005
R729 VSS.n1402 VSS.n1401 52.5005
R730 VSS.n1398 VSS.n1397 52.5005
R731 VSS.n1392 VSS.n1391 52.5005
R732 VSS.n1351 VSS.n1228 52.5005
R733 VSS.n1351 VSS.n1218 52.5005
R734 VSS.n1305 VSS.n1218 52.5005
R735 VSS.n1305 VSS.n1205 52.5005
R736 VSS.n1296 VSS.n1205 52.5005
R737 VSS.n1296 VSS.n1192 52.5005
R738 VSS.n1416 VSS.n1192 52.5005
R739 VSS.n1416 VSS.n1180 52.5005
R740 VSS.n1672 VSS.n1671 52.5005
R741 VSS.n1676 VSS.n1240 52.5005
R742 VSS.n1679 VSS.n1678 52.5005
R743 VSS.n1681 VSS.n1234 52.5005
R744 VSS.n416 VSS.n123 52.5005
R745 VSS.n863 VSS.n416 52.5005
R746 VSS.n863 VSS.n413 52.5005
R747 VSS.n867 VSS.n413 52.5005
R748 VSS.n867 VSS.n412 52.5005
R749 VSS.n493 VSS.n412 52.5005
R750 VSS.n802 VSS.n493 52.5005
R751 VSS.n802 VSS.n492 52.5005
R752 VSS.n781 VSS.n515 52.5005
R753 VSS.n785 VSS.n497 52.5005
R754 VSS.n788 VSS.n497 52.5005
R755 VSS.n794 VSS.n517 52.5005
R756 VSS.n794 VSS.n495 52.5005
R757 VSS.n902 VSS.n129 52.5005
R758 VSS.n418 VSS.n129 52.5005
R759 VSS.n439 VSS.n418 52.5005
R760 VSS.n439 VSS.n403 52.5005
R761 VSS.n429 VSS.n403 52.5005
R762 VSS.n523 VSS.n429 52.5005
R763 VSS.n523 VSS.n485 52.5005
R764 VSS.n778 VSS.n485 52.5005
R765 VSS.n911 VSS.n910 52.5005
R766 VSS.n915 VSS.n914 52.5005
R767 VSS.n919 VSS.n918 52.5005
R768 VSS.n923 VSS.n124 52.5005
R769 VSS.n1687 VSS.n1224 52.5005
R770 VSS.n1691 VSS.n1224 52.5005
R771 VSS.n1691 VSS.n1202 52.5005
R772 VSS.n1699 VSS.n1202 52.5005
R773 VSS.n1699 VSS.n1199 52.5005
R774 VSS.n1703 VSS.n1199 52.5005
R775 VSS.n1703 VSS.n1198 52.5005
R776 VSS.n1198 VSS.n1175 52.5005
R777 VSS.n1716 VSS.n1715 52.5005
R778 VSS.n1720 VSS.n1719 52.5005
R779 VSS.n1722 VSS.n1173 52.5005
R780 VSS.n1174 VSS.n1173 52.5005
R781 VSS.n1350 VSS.n1227 52.5005
R782 VSS.n1350 VSS.n1217 52.5005
R783 VSS.n1304 VSS.n1217 52.5005
R784 VSS.n1304 VSS.n1204 52.5005
R785 VSS.n1295 VSS.n1204 52.5005
R786 VSS.n1295 VSS.n1191 52.5005
R787 VSS.n1191 VSS.n1179 52.5005
R788 VSS.n1711 VSS.n1179 52.5005
R789 VSS.n1270 VSS.n1252 52.5005
R790 VSS.n1266 VSS.n1264 52.5005
R791 VSS.n1262 VSS.n1254 52.5005
R792 VSS.n1256 VSS.n1226 52.5005
R793 VSS.n26 VSS.n11 52.5005
R794 VSS.n1073 VSS.n26 52.5005
R795 VSS.n1073 VSS.n23 52.5005
R796 VSS.n1068 VSS.n23 52.5005
R797 VSS.n1068 VSS.n28 52.5005
R798 VSS.n1059 VSS.n28 52.5005
R799 VSS.n1059 VSS.n37 52.5005
R800 VSS.n1055 VSS.n37 52.5005
R801 VSS.n1055 VSS.n39 52.5005
R802 VSS.n189 VSS.n39 52.5005
R803 VSS.n208 VSS.n155 52.5005
R804 VSS.n202 VSS.n201 52.5005
R805 VSS.n198 VSS.n197 52.5005
R806 VSS.n194 VSS.n193 52.5005
R807 VSS.n1079 VSS.n19 52.5005
R808 VSS.n1075 VSS.n19 52.5005
R809 VSS.n1075 VSS.n21 52.5005
R810 VSS.n1065 VSS.n21 52.5005
R811 VSS.n1065 VSS.n30 52.5005
R812 VSS.n1061 VSS.n30 52.5005
R813 VSS.n1061 VSS.n32 52.5005
R814 VSS.n40 VSS.n32 52.5005
R815 VSS.n214 VSS.n40 52.5005
R816 VSS.n214 VSS.n187 52.5005
R817 VSS.n1088 VSS.n1087 52.5005
R818 VSS.n1092 VSS.n1091 52.5005
R819 VSS.n1096 VSS.n1095 52.5005
R820 VSS.n1100 VSS.n12 52.5005
R821 VSS.n253 VSS.n252 52.5005
R822 VSS.n249 VSS.n248 52.5005
R823 VSS.n245 VSS.n244 52.5005
R824 VSS.n239 VSS.n238 52.5005
R825 VSS.n236 VSS.n223 52.5005
R826 VSS.n232 VSS.n230 52.5005
R827 VSS.n375 VSS.n153 52.5005
R828 VSS.n365 VSS.n364 52.5005
R829 VSS.n367 VSS.n166 52.5005
R830 VSS.n167 VSS.n166 52.5005
R831 VSS.n386 VSS.n149 52.5005
R832 VSS.n341 VSS.n340 52.5005
R833 VSS.n345 VSS.n336 52.5005
R834 VSS.n1002 VSS.n58 52.5005
R835 VSS.n1006 VSS.n1005 52.5005
R836 VSS.n1008 VSS.n62 52.5005
R837 VSS.n63 VSS.n62 52.5005
R838 VSS.n329 VSS.n41 52.5005
R839 VSS.n325 VSS.n41 52.5005
R840 VSS.n325 VSS.n324 52.5005
R841 VSS.n324 VSS.n184 52.5005
R842 VSS.n314 VSS.n184 52.5005
R843 VSS.n314 VSS.n288 52.5005
R844 VSS.n309 VSS.n288 52.5005
R845 VSS.n309 VSS.n308 52.5005
R846 VSS.n308 VSS.n85 52.5005
R847 VSS.n304 VSS.n85 52.5005
R848 VSS.n304 VSS.n78 52.5005
R849 VSS.n297 VSS.n78 52.5005
R850 VSS.n297 VSS.n296 52.5005
R851 VSS.n296 VSS.n67 52.5005
R852 VSS.n67 VSS.n57 52.5005
R853 VSS.n1037 VSS.n1036 52.5005
R854 VSS.n1041 VSS.n1040 52.5005
R855 VSS.n1045 VSS.n51 52.5005
R856 VSS.n1048 VSS.n46 52.5005
R857 VSS.n1052 VSS.n43 52.5005
R858 VSS.n1052 VSS.n42 52.5005
R859 VSS.n322 VSS.n42 52.5005
R860 VSS.n322 VSS.n281 52.5005
R861 VSS.n318 VSS.n281 52.5005
R862 VSS.n318 VSS.n285 52.5005
R863 VSS.n285 VSS.n284 52.5005
R864 VSS.n284 VSS.n84 52.5005
R865 VSS.n981 VSS.n84 52.5005
R866 VSS.n981 VSS.n81 52.5005
R867 VSS.n985 VSS.n81 52.5005
R868 VSS.n985 VSS.n80 52.5005
R869 VSS.n80 VSS.n66 52.5005
R870 VSS.n999 VSS.n66 52.5005
R871 VSS.n999 VSS.n64 52.5005
R872 VSS.n599 VSS.n550 50.7505
R873 VSS.n594 VSS.n552 50.7505
R874 VSS.n941 VSS.n940 50.7505
R875 VSS.n972 VSS.n88 50.7505
R876 VSS.n1748 VSS.n1104 50.7505
R877 VSS.n1750 VSS.n4 50.7505
R878 VSS.n1541 VSS.n1373 50.7505
R879 VSS.n1571 VSS.n1375 50.7505
R880 VSS.n1080 VSS.n1079 50.7505
R881 VSS.n1100 VSS.n11 50.7505
R882 VSS.n1017 VSS.n57 50.7505
R883 VSS.n329 VSS.n182 50.7505
R884 VSS.n646 VSS.n632 42.0005
R885 VSS.n644 VSS.n633 42.0005
R886 VSS.n655 VSS.n627 42.0005
R887 VSS.n662 VSS.n630 42.0005
R888 VSS.n1287 VSS.n1283 42.0005
R889 VSS.n1640 VSS.n1284 42.0005
R890 VSS.n1648 VSS.n1279 42.0005
R891 VSS.n1653 VSS.n1281 42.0005
R892 VSS.n528 VSS.n508 42.0005
R893 VSS.n447 VSS.n133 42.0005
R894 VSS.n1182 VSS.n1164 42.0005
R895 VSS.n1316 VSS.n1230 42.0005
R896 VSS.n527 VSS.n510 42.0005
R897 VSS.n819 VSS.n132 42.0005
R898 VSS.n1181 VSS.n1166 42.0005
R899 VSS.n1600 VSS.n1229 42.0005
R900 VSS.n526 VSS.n503 42.0005
R901 VSS.n878 VSS.n131 42.0005
R902 VSS.n1180 VSS.n1159 42.0005
R903 VSS.n1669 VSS.n1228 42.0005
R904 VSS.n778 VSS.n515 42.0005
R905 VSS.n903 VSS.n902 42.0005
R906 VSS.n1712 VSS.n1711 42.0005
R907 VSS.n1272 VSS.n1227 42.0005
R908 VSS.n190 VSS.n189 42.0005
R909 VSS.n187 VSS.n155 42.0005
R910 VSS.n241 VSS.n175 42.0005
R911 VSS.n269 VSS.n268 42.0005
R912 VSS.n372 VSS.n168 42.0005
R913 VSS.n389 VSS.n388 42.0005
R914 VSS.n1048 VSS.n43 42.0005
R915 VSS.n1013 VSS.n64 42.0005
R916 VSS.n599 VSS.n548 35.0005
R917 VSS.n594 VSS.n542 35.0005
R918 VSS.n1748 VSS.n1105 35.0005
R919 VSS.n1750 VSS.n5 35.0005
R920 VSS.n662 VSS.n629 35.0005
R921 VSS.n629 VSS.n408 35.0005
R922 VSS.n647 VSS.n408 35.0005
R923 VSS.n647 VSS.n646 35.0005
R924 VSS.n627 VSS.n401 35.0005
R925 VSS.n869 VSS.n401 35.0005
R926 VSS.n869 VSS.n400 35.0005
R927 VSS.n644 VSS.n400 35.0005
R928 VSS.n1657 VSS.n1281 35.0005
R929 VSS.n1657 VSS.n1210 35.0005
R930 VSS.n1642 VSS.n1210 35.0005
R931 VSS.n1642 VSS.n1283 35.0005
R932 VSS.n1658 VSS.n1279 35.0005
R933 VSS.n1658 VSS.n1208 35.0005
R934 VSS.n1641 VSS.n1208 35.0005
R935 VSS.n1641 VSS.n1640 35.0005
R936 VSS.n225 VSS.n179 35.0005
R937 VSS.n354 VSS.n179 35.0005
R938 VSS.n354 VSS.n176 35.0005
R939 VSS.n358 VSS.n176 35.0005
R940 VSS.n358 VSS.n175 35.0005
R941 VSS.n270 VSS.n269 35.0005
R942 VSS.n270 VSS.n181 35.0005
R943 VSS.n274 VSS.n181 35.0005
R944 VSS.n274 VSS.n173 35.0005
R945 VSS.n186 VSS.n173 35.0005
R946 VSS.n348 VSS.n334 35.0005
R947 VSS.n352 VSS.n334 35.0005
R948 VSS.n352 VSS.n170 35.0005
R949 VSS.n360 VSS.n170 35.0005
R950 VSS.n360 VSS.n168 35.0005
R951 VSS.n389 VSS.n148 35.0005
R952 VSS.n180 VSS.n148 35.0005
R953 VSS.n218 VSS.n180 35.0005
R954 VSS.n218 VSS.n172 35.0005
R955 VSS.n172 VSS.n154 35.0005
R956 VSS.n18 VSS.n1 31.8896
R957 VSS.n396 VSS.n395 26.7421
R958 VSS.n640 VSS.n636 26.2505
R959 VSS.n658 VSS.n657 26.2505
R960 VSS.n1291 VSS.n1289 26.2505
R961 VSS.n1651 VSS.n1650 26.2505
R962 VSS.n1666 VSS.n1274 25.5037
R963 VSS.n876 VSS.n128 25.5037
R964 VSS.n228 VSS.n225 24.5005
R965 VSS.n348 VSS.n347 24.5005
R966 VSS.n971 VSS.n92 22.0943
R967 VSS.n1443 VSS.t113 20.9343
R968 VSS.n1330 VSS.t272 20.9343
R969 VSS.n1394 VSS.t194 20.9343
R970 VSS.n1238 VSS.t54 20.9343
R971 VSS.n1725 VSS.t250 20.9343
R972 VSS.n1260 VSS.t96 20.9343
R973 VSS.n1477 VSS.t247 20.9343
R974 VSS.n1614 VSS.t274 20.9343
R975 VSS.n758 VSS.n757 20.8087
R976 VSS.n784 VSS.n783 20.8087
R977 VSS.n725 VSS.n724 20.8087
R978 VSS.n688 VSS.n687 20.8087
R979 VSS.n768 VSS.t51 20.7305
R980 VSS.n140 VSS.t260 20.7305
R981 VSS.n792 VSS.t27 20.7305
R982 VSS.n127 VSS.t252 20.7305
R983 VSS.n735 VSS.t276 20.7305
R984 VSS.n818 VSS.t278 20.7305
R985 VSS.n698 VSS.t85 20.7305
R986 VSS.n446 VSS.t187 20.7305
R987 VSS.n1433 VSS.n1421 20.6665
R988 VSS.n1406 VSS.n1404 20.6665
R989 VSS.n1714 VSS.n1177 20.6665
R990 VSS.n1467 VSS.n1455 20.6665
R991 VSS.n1442 VSS.t114 20.3983
R992 VSS.n1331 VSS.t273 20.3983
R993 VSS.n1395 VSS.t195 20.3983
R994 VSS.n1237 VSS.t55 20.3983
R995 VSS.n1724 VSS.t251 20.3983
R996 VSS.n1259 VSS.t97 20.3983
R997 VSS.n1476 VSS.t248 20.3983
R998 VSS.n1615 VSS.t275 20.3983
R999 VSS.t177 VSS.n92 20.3268
R1000 VSS.n767 VSS.t52 20.2975
R1001 VSS.n139 VSS.t261 20.2975
R1002 VSS.n791 VSS.t28 20.2975
R1003 VSS.n126 VSS.t253 20.2975
R1004 VSS.n734 VSS.t277 20.2975
R1005 VSS.n817 VSS.t279 20.2975
R1006 VSS.n697 VSS.t86 20.2975
R1007 VSS.n445 VSS.t188 20.2975
R1008 VSS.n392 VSS.n145 20.0947
R1009 VSS.n266 VSS.n144 18.8581
R1010 VSS.n1573 VSS.n1572 18.6477
R1011 VSS.n1753 VSS.n1752 18.5479
R1012 VSS.n1576 VSS.n1575 18.4521
R1013 VSS.n592 VSS.n0 18.4163
R1014 VSS.n1667 VSS.n1666 18.0147
R1015 VSS.n877 VSS.n876 18.0147
R1016 VSS.n392 VSS.n391 18.0005
R1017 VSS.n1665 VSS.n1275 17.9697
R1018 VSS.n875 VSS.n142 17.9697
R1019 VSS.n1663 VSS.n1276 17.9614
R1020 VSS.n873 VSS.n397 17.9614
R1021 VSS.n1749 VSS.n1103 17.6756
R1022 VSS.n598 VSS.n597 17.6756
R1023 VSS.n1734 VSS.n1733 17.4104
R1024 VSS.n1736 VSS.n1735 17.4104
R1025 VSS.n1738 VSS.n1737 17.4104
R1026 VSS.n1740 VSS.n1739 17.4104
R1027 VSS.n1742 VSS.n1741 17.4104
R1028 VSS.n1148 VSS.n1147 17.4104
R1029 VSS.n534 VSS.n532 17.4104
R1030 VSS.n611 VSS.n610 17.4104
R1031 VSS.n613 VSS.n612 17.4104
R1032 VSS.n545 VSS.n539 17.4104
R1033 VSS.n547 VSS.n546 17.4104
R1034 VSS.n595 VSS.n543 17.4104
R1035 VSS.n1625 VSS.n1355 16.4383
R1036 VSS.n1488 VSS.n1487 16.4383
R1037 VSS.n843 VSS.n476 16.4383
R1038 VSS.n803 VSS.n484 16.4383
R1039 VSS.t5 VSS.n6 15.908
R1040 VSS.n1753 VSS.n1 14.9016
R1041 VSS.n1664 VSS.n1 14.6397
R1042 VSS.n874 VSS.n396 14.6397
R1043 VSS.n1661 VSS.t216 14.3735
R1044 VSS.n871 VSS.t219 14.3735
R1045 VSS.n1577 VSS.n1370 14.2289
R1046 VSS.n1698 VSS.n1203 14.2289
R1047 VSS.n868 VSS.n402 14.2289
R1048 VSS.t196 VSS.t88 14.1405
R1049 VSS.t29 VSS.t65 14.1405
R1050 VSS.n1534 VSS.n1366 14.0334
R1051 VSS.n1588 VSS.n1587 14.0334
R1052 VSS.n1662 VSS.t131 14.0135
R1053 VSS.n872 VSS.t221 14.0135
R1054 VSS.n939 VSS.t179 13.2568
R1055 VSS.n1321 VSS.n1320 13.0239
R1056 VSS.n1246 VSS.n1245 13.0239
R1057 VSS.n1251 VSS.n1250 13.0239
R1058 VSS.n1605 VSS.n1604 13.0239
R1059 VSS.n883 VSS.n882 13.0239
R1060 VSS.n908 VSS.n907 13.0239
R1061 VSS.n824 VSS.n823 13.0239
R1062 VSS.n452 VSS.n451 13.0239
R1063 VSS.n1085 VSS.n1084 13.022
R1064 VSS.n17 VSS.n16 13.022
R1065 VSS.n207 VSS.n206 12.392
R1066 VSS.n928 VSS.n927 12.0195
R1067 VSS.n1361 VSS.n1236 11.5777
R1068 VSS.n1732 VSS.n1731 11.5777
R1069 VSS.n925 VSS.n924 11.5777
R1070 VSS.n795 VSS.n496 11.5777
R1071 VSS.n1572 VSS.n1374 11.4893
R1072 VSS.n1749 VSS.n1102 11.4893
R1073 VSS.n1101 VSS.n6 11.4893
R1074 VSS.n287 VSS.t184 11.4893
R1075 VSS.n598 VSS.n551 11.4893
R1076 VSS.n1034 VSS.n1033 11.2705
R1077 VSS.n1020 VSS.n1019 11.2705
R1078 VSS.n1027 VSS.n53 11.1282
R1079 VSS.n1026 VSS.n54 11.1282
R1080 VSS.n259 VSS.n258 10.2705
R1081 VSS.n384 VSS.n383 10.2705
R1082 VSS.n378 VSS.n377 10.2705
R1083 VSS.n265 VSS.n264 10.2705
R1084 VSS.n1584 VSS.n1583 9.81015
R1085 VSS.n1586 VSS.n1585 9.81015
R1086 VSS.n997 VSS.n68 9.81015
R1087 VSS.n996 VSS.n995 9.81015
R1088 VSS.t76 VSS.n1195 9.72178
R1089 VSS.n1047 VSS.n47 9.72178
R1090 VSS.n638 VSS.t168 9.72178
R1091 VSS.n1661 VSS.n1660 9.66958
R1092 VSS.n871 VSS.n870 9.66958
R1093 VSS.n1583 VSS.n1366 9.61459
R1094 VSS.n1587 VSS.n1586 9.61459
R1095 VSS.n596 VSS.n595 9.0343
R1096 VSS.n546 VSS.n545 9.0343
R1097 VSS.n612 VSS.n611 9.0343
R1098 VSS.n534 VSS.n496 9.0343
R1099 VSS.n804 VSS.n481 9.0343
R1100 VSS.n428 VSS.n402 9.0343
R1101 VSS.n628 VSS.n443 9.0343
R1102 VSS.n471 VSS.n470 9.0343
R1103 VSS.n926 VSS.n925 9.0343
R1104 VSS.n997 VSS.n996 9.0343
R1105 VSS.n988 VSS.n987 9.0343
R1106 VSS.n979 VSS.n978 9.0343
R1107 VSS.n1147 VSS.n1146 9.0343
R1108 VSS.n1741 VSS.n1740 9.0343
R1109 VSS.n1737 VSS.n1736 9.0343
R1110 VSS.n1733 VSS.n1732 9.0343
R1111 VSS.n1420 VSS.n1389 9.0343
R1112 VSS.n1638 VSS.n1203 9.0343
R1113 VSS.n1308 VSS.n1280 9.0343
R1114 VSS.n1341 VSS.n1340 9.0343
R1115 VSS.n1362 VSS.n1361 9.0343
R1116 VSS.n1585 VSS.n1584 9.0343
R1117 VSS.n1533 VSS.n1370 9.0343
R1118 VSS.n1574 VSS.n1573 9.0343
R1119 VSS.n1698 VSS.n1209 8.83803
R1120 VSS.n36 VSS.t24 8.83803
R1121 VSS.n868 VSS.n407 8.83803
R1122 VSS.t183 VSS.n286 8.04265
R1123 VSS.n1047 VSS.n33 7.95427
R1124 VSS.n315 VSS.t126 7.95427
R1125 VSS.t124 VSS.n986 7.95427
R1126 VSS.n1355 VSS.t112 7.8659
R1127 VSS.n1735 VSS.t63 7.8659
R1128 VSS.n1738 VSS.t95 7.8659
R1129 VSS.t256 VSS.n1742 7.8659
R1130 VSS.n927 VSS.t87 7.8659
R1131 VSS.n476 VSS.t234 7.8659
R1132 VSS.n610 VSS.t249 7.8659
R1133 VSS.t108 VSS.n613 7.8659
R1134 VSS.t254 VSS.n547 7.8659
R1135 VSS VSS.n1753 7.73966
R1136 VSS.n1666 VSS.n1665 7.53445
R1137 VSS.n876 VSS.n875 7.53445
R1138 VSS.n1664 VSS.n1663 7.49527
R1139 VSS.n874 VSS.n873 7.49527
R1140 VSS.n1663 VSS.n1662 7.43328
R1141 VSS.n873 VSS.n872 7.43328
R1142 VSS.n977 VSS.n86 7.1589
R1143 VSS.n25 VSS.t244 7.07052
R1144 VSS.n25 VSS.t164 7.07052
R1145 VSS.t60 VSS.t268 7.07052
R1146 VSS.t268 VSS.t30 7.07052
R1147 VSS.t190 VSS.t4 7.07052
R1148 VSS.t161 VSS.t190 7.07052
R1149 VSS.n35 VSS.t23 7.07052
R1150 VSS.t67 VSS.n35 7.07052
R1151 VSS.n1060 VSS.n36 7.07052
R1152 VSS.t81 VSS.t245 7.07052
R1153 VSS.t199 VSS.t62 7.07052
R1154 VSS.n939 VSS.n91 7.07052
R1155 VSS.n1489 VSS.t102 6.62864
R1156 VSS.n1743 VSS.t256 6.62864
R1157 VSS.t300 VSS.n672 6.62864
R1158 VSS.n604 VSS.t254 6.62864
R1159 VSS.n380 VSS.n379 6.5388
R1160 VSS.n382 VSS.n381 6.5388
R1161 VSS.n261 VSS.n260 6.5388
R1162 VSS.n263 VSS.n262 6.5388
R1163 VSS.n206 VSS.n204 6.3881
R1164 VSS.n206 VSS.n205 6.38518
R1165 VSS.n1022 VSS.n1021 6.29333
R1166 VSS.n1024 VSS.n1023 6.29333
R1167 VSS.n1030 VSS.n1029 6.29333
R1168 VSS.n1032 VSS.n1031 6.29333
R1169 VSS.n1692 VSS.n1216 6.18677
R1170 VSS.n1704 VSS.n1195 6.18677
R1171 VSS.n862 VSS.n417 6.18677
R1172 VSS.n638 VSS.n483 6.18677
R1173 VSS.n1573 VSS.t100 6.09839
R1174 VSS.n1574 VSS.t101 6.09839
R1175 VSS.t106 VSS.n1370 6.09839
R1176 VSS.n1533 VSS.t107 6.09839
R1177 VSS.n1584 VSS.t0 6.09839
R1178 VSS.n1585 VSS.t1 6.09839
R1179 VSS.n1362 VSS.t33 6.09839
R1180 VSS.n1361 VSS.t34 6.09839
R1181 VSS.n1733 VSS.t223 6.09839
R1182 VSS.n1736 VSS.t156 6.09839
R1183 VSS.n1737 VSS.t157 6.09839
R1184 VSS.n1740 VSS.t258 6.09839
R1185 VSS.n1147 VSS.t192 6.09839
R1186 VSS.n1146 VSS.t193 6.09839
R1187 VSS.n996 VSS.t160 6.09839
R1188 VSS.n926 VSS.t31 6.09839
R1189 VSS.n925 VSS.t32 6.09839
R1190 VSS.t99 VSS.n534 6.09839
R1191 VSS.n611 VSS.t228 6.09839
R1192 VSS.n612 VSS.t229 6.09839
R1193 VSS.n545 VSS.t270 6.09839
R1194 VSS.n595 VSS.t242 6.09839
R1195 VSS.n596 VSS.t243 6.09839
R1196 VSS.n1320 VSS.n1319 5.83696
R1197 VSS.n1245 VSS.n1244 5.83696
R1198 VSS.n1250 VSS.n1249 5.83696
R1199 VSS.n1604 VSS.n1603 5.83696
R1200 VSS.n1320 VSS.n1318 5.83371
R1201 VSS.n1245 VSS.n1243 5.83371
R1202 VSS.n1250 VSS.n1248 5.83371
R1203 VSS.n1604 VSS.n1602 5.83371
R1204 VSS.n1731 VSS.n1165 5.83327
R1205 VSS.n69 VSS.n60 5.83327
R1206 VSS.n795 VSS.n509 5.83327
R1207 VSS.n1084 VSS.n1083 5.73984
R1208 VSS.n16 VSS.n15 5.73984
R1209 VSS.n1084 VSS.n1082 5.73692
R1210 VSS.n16 VSS.n14 5.73692
R1211 VSS.n1686 VSS.n1231 5.65652
R1212 VSS.n1710 VSS.n1165 5.65652
R1213 VSS.n1734 VSS.n1152 5.65652
R1214 VSS.n1739 VSS.n1151 5.65652
R1215 VSS.n302 VSS.t9 5.65652
R1216 VSS.n1015 VSS.n60 5.65652
R1217 VSS.n901 VSS.n134 5.65652
R1218 VSS.n777 VSS.n509 5.65652
R1219 VSS.n621 VSS.n532 5.65652
R1220 VSS.n614 VSS.n539 5.65652
R1221 VSS.n882 VSS.n881 5.5383
R1222 VSS.n907 VSS.n906 5.5383
R1223 VSS.n823 VSS.n822 5.5383
R1224 VSS.n451 VSS.n450 5.5383
R1225 VSS.n882 VSS.n880 5.53505
R1226 VSS.n907 VSS.n905 5.53505
R1227 VSS.n823 VSS.n821 5.53505
R1228 VSS.n451 VSS.n449 5.53505
R1229 VSS.n547 VSS.n543 5.41246
R1230 VSS.n613 VSS.n539 5.41246
R1231 VSS.n610 VSS.n532 5.41246
R1232 VSS.n509 VSS.n484 5.41246
R1233 VSS.n476 VSS.n134 5.41246
R1234 VSS.n927 VSS.n60 5.41246
R1235 VSS.n294 VSS.n293 5.41246
R1236 VSS.n302 VSS.n301 5.41246
R1237 VSS.n1742 VSS.n1148 5.41246
R1238 VSS.n1739 VSS.n1738 5.41246
R1239 VSS.n1735 VSS.n1734 5.41246
R1240 VSS.n1488 VSS.n1165 5.41246
R1241 VSS.n1355 VSS.n1231 5.41246
R1242 VSS.n1534 VSS.n1533 5.39139
R1243 VSS.n1588 VSS.n1362 5.39139
R1244 VSS.n1692 VSS.n1221 5.39139
R1245 VSS.n1280 VSS.n1209 5.39139
R1246 VSS.n1704 VSS.n1190 5.39139
R1247 VSS.n928 VSS.n926 5.39139
R1248 VSS.n862 VSS.n422 5.39139
R1249 VSS.n628 VSS.n407 5.39139
R1250 VSS.n806 VSS.n483 5.39139
R1251 VSS.t61 VSS.t255 5.30302
R1252 VSS.n185 VSS.t115 5.30302
R1253 VSS.t40 VSS.t257 5.30302
R1254 VSS.n980 VSS.t104 5.30302
R1255 VSS.t185 VSS.t8 5.30302
R1256 VSS.n998 VSS.t159 5.30302
R1257 VSS.n591 VSS.n552 5.2005
R1258 VSS.n590 VSS.n589 5.2005
R1259 VSS.n587 VSS.n553 5.2005
R1260 VSS.n585 VSS.n584 5.2005
R1261 VSS.n583 VSS.n554 5.2005
R1262 VSS.n582 VSS.n581 5.2005
R1263 VSS.n579 VSS.n555 5.2005
R1264 VSS.n577 VSS.n576 5.2005
R1265 VSS.n575 VSS.n556 5.2005
R1266 VSS.n574 VSS.n573 5.2005
R1267 VSS.n571 VSS.n557 5.2005
R1268 VSS.n569 VSS.n568 5.2005
R1269 VSS.n567 VSS.n558 5.2005
R1270 VSS.n566 VSS.n565 5.2005
R1271 VSS.n563 VSS.n551 5.2005
R1272 VSS.n563 VSS.n559 5.2005
R1273 VSS.n562 VSS.n560 5.2005
R1274 VSS.n550 VSS.n549 5.2005
R1275 VSS.n598 VSS.n594 5.2005
R1276 VSS.n594 VSS.n593 5.2005
R1277 VSS.n597 VSS.n542 5.2005
R1278 VSS.n542 VSS.n541 5.2005
R1279 VSS.n605 VSS.n604 5.2005
R1280 VSS.n606 VSS.n605 5.2005
R1281 VSS.n544 VSS.n540 5.2005
R1282 VSS.n607 VSS.n540 5.2005
R1283 VSS.n614 VSS.n609 5.2005
R1284 VSS.n609 VSS.n608 5.2005
R1285 VSS.t212 VSS.n531 5.2005
R1286 VSS.n531 VSS.n530 5.2005
R1287 VSS.n622 VSS.n621 5.2005
R1288 VSS.n623 VSS.n622 5.2005
R1289 VSS.n535 VSS.n529 5.2005
R1290 VSS.n624 VSS.n529 5.2005
R1291 VSS.n672 VSS.n671 5.2005
R1292 VSS.n671 VSS.n670 5.2005
R1293 VSS.n807 VSS.n482 5.2005
R1294 VSS.n669 VSS.n482 5.2005
R1295 VSS.n855 VSS.n433 5.2005
R1296 VSS.n668 VSS.n433 5.2005
R1297 VSS.n666 VSS.n407 5.2005
R1298 VSS.n667 VSS.n666 5.2005
R1299 VSS.n665 VSS.n664 5.2005
R1300 VSS.n665 VSS.n626 5.2005
R1301 VSS.n843 VSS.n475 5.2005
R1302 VSS.n625 VSS.n475 5.2005
R1303 VSS.n103 VSS.n102 5.2005
R1304 VSS.n102 VSS.n101 5.2005
R1305 VSS.n929 VSS.n928 5.2005
R1306 VSS.n930 VSS.n929 5.2005
R1307 VSS.n995 VSS.n70 5.2005
R1308 VSS.n931 VSS.n70 5.2005
R1309 VSS.n932 VSS.n68 5.2005
R1310 VSS.n933 VSS.n932 5.2005
R1311 VSS.n989 VSS.n76 5.2005
R1312 VSS.n934 VSS.n76 5.2005
R1313 VSS.n935 VSS.n79 5.2005
R1314 VSS.n936 VSS.n935 5.2005
R1315 VSS.n977 VSS.n87 5.2005
R1316 VSS.n937 VSS.n87 5.2005
R1317 VSS.n940 VSS.n939 5.2005
R1318 VSS.n940 VSS.n938 5.2005
R1319 VSS.n972 VSS.n971 5.2005
R1320 VSS.n973 VSS.n972 5.2005
R1321 VSS.n90 VSS.n89 5.2005
R1322 VSS.n969 VSS.n968 5.2005
R1323 VSS.n967 VSS.n100 5.2005
R1324 VSS.n966 VSS.n965 5.2005
R1325 VSS.n964 VSS.n963 5.2005
R1326 VSS.n962 VSS.n961 5.2005
R1327 VSS.n960 VSS.n959 5.2005
R1328 VSS.n958 VSS.n957 5.2005
R1329 VSS.n956 VSS.n955 5.2005
R1330 VSS.n954 VSS.n953 5.2005
R1331 VSS.n952 VSS.n951 5.2005
R1332 VSS.n950 VSS.n949 5.2005
R1333 VSS.n948 VSS.n947 5.2005
R1334 VSS.n946 VSS.n945 5.2005
R1335 VSS.n944 VSS.n943 5.2005
R1336 VSS.n942 VSS.n941 5.2005
R1337 VSS.n599 VSS.n598 5.2005
R1338 VSS.n600 VSS.n599 5.2005
R1339 VSS.n597 VSS.n548 5.2005
R1340 VSS.n601 VSS.n548 5.2005
R1341 VSS.n604 VSS.n603 5.2005
R1342 VSS.n603 VSS.n602 5.2005
R1343 VSS.n544 VSS.n538 5.2005
R1344 VSS.n538 VSS.n537 5.2005
R1345 VSS.n615 VSS.n614 5.2005
R1346 VSS.n616 VSS.n615 5.2005
R1347 VSS.t212 VSS.n533 5.2005
R1348 VSS.n617 VSS.n533 5.2005
R1349 VSS.n621 VSS.n620 5.2005
R1350 VSS.n620 VSS.n619 5.2005
R1351 VSS.n536 VSS.n535 5.2005
R1352 VSS.n618 VSS.n536 5.2005
R1353 VSS.n672 VSS.n480 5.2005
R1354 VSS.n480 VSS.n479 5.2005
R1355 VSS.n808 VSS.n807 5.2005
R1356 VSS.n809 VSS.n808 5.2005
R1357 VSS.n855 VSS.n434 5.2005
R1358 VSS.n810 VSS.n434 5.2005
R1359 VSS.n811 VSS.n407 5.2005
R1360 VSS.n812 VSS.n811 5.2005
R1361 VSS.n664 VSS.n477 5.2005
R1362 VSS.n813 VSS.n477 5.2005
R1363 VSS.n843 VSS.n816 5.2005
R1364 VSS.n816 VSS.n815 5.2005
R1365 VSS.n478 VSS.n103 5.2005
R1366 VSS.n814 VSS.n478 5.2005
R1367 VSS.n928 VSS.n71 5.2005
R1368 VSS.n73 VSS.n71 5.2005
R1369 VSS.n995 VSS.n994 5.2005
R1370 VSS.n994 VSS.n993 5.2005
R1371 VSS.n72 VSS.n68 5.2005
R1372 VSS.n992 VSS.n72 5.2005
R1373 VSS.n990 VSS.n989 5.2005
R1374 VSS.n991 VSS.n990 5.2005
R1375 VSS.n79 VSS.n75 5.2005
R1376 VSS.n75 VSS.n74 5.2005
R1377 VSS.n977 VSS.n976 5.2005
R1378 VSS.n976 VSS.n975 5.2005
R1379 VSS.n939 VSS.n88 5.2005
R1380 VSS.n974 VSS.n88 5.2005
R1381 VSS.n330 VSS.n43 5.2005
R1382 VSS.n1050 VSS.n43 5.2005
R1383 VSS.n1053 VSS.n1052 5.2005
R1384 VSS.n1052 VSS.n1051 5.2005
R1385 VSS.n171 VSS.n42 5.2005
R1386 VSS.n44 VSS.n42 5.2005
R1387 VSS.n323 VSS.n322 5.2005
R1388 VSS.n322 VSS.n321 5.2005
R1389 VSS.n315 VSS.n281 5.2005
R1390 VSS.n320 VSS.n281 5.2005
R1391 VSS.n318 VSS.n317 5.2005
R1392 VSS.n319 VSS.n318 5.2005
R1393 VSS.n287 VSS.n285 5.2005
R1394 VSS.n285 VSS.n282 5.2005
R1395 VSS.n284 VSS.n92 5.2005
R1396 VSS.n284 VSS.n283 5.2005
R1397 VSS.n91 VSS.n84 5.2005
R1398 VSS.n84 VSS.n83 5.2005
R1399 VSS.n981 VSS.n980 5.2005
R1400 VSS.n982 VSS.n981 5.2005
R1401 VSS.n303 VSS.n81 5.2005
R1402 VSS.n983 VSS.n81 5.2005
R1403 VSS.n986 VSS.n985 5.2005
R1404 VSS.n985 VSS.n984 5.2005
R1405 VSS.n80 VSS.n77 5.2005
R1406 VSS.n82 VSS.n80 5.2005
R1407 VSS.n295 VSS.n66 5.2005
R1408 VSS.n66 VSS.n65 5.2005
R1409 VSS.n999 VSS.n998 5.2005
R1410 VSS.n1000 VSS.n999 5.2005
R1411 VSS.n69 VSS.n64 5.2005
R1412 VSS.n1001 VSS.n64 5.2005
R1413 VSS.n69 VSS.n57 5.2005
R1414 VSS.n57 VSS.n56 5.2005
R1415 VSS.n998 VSS.n67 5.2005
R1416 VSS.n289 VSS.n67 5.2005
R1417 VSS.n296 VSS.n295 5.2005
R1418 VSS.n296 VSS.n290 5.2005
R1419 VSS.n297 VSS.n77 5.2005
R1420 VSS.n298 VSS.n297 5.2005
R1421 VSS.n986 VSS.n78 5.2005
R1422 VSS.n299 VSS.n78 5.2005
R1423 VSS.n304 VSS.n303 5.2005
R1424 VSS.n305 VSS.n304 5.2005
R1425 VSS.n980 VSS.n85 5.2005
R1426 VSS.n306 VSS.n85 5.2005
R1427 VSS.n308 VSS.n91 5.2005
R1428 VSS.n308 VSS.n307 5.2005
R1429 VSS.n309 VSS.n92 5.2005
R1430 VSS.n310 VSS.n309 5.2005
R1431 VSS.n288 VSS.n287 5.2005
R1432 VSS.n311 VSS.n288 5.2005
R1433 VSS.n317 VSS.n314 5.2005
R1434 VSS.n314 VSS.n313 5.2005
R1435 VSS.n315 VSS.n184 5.2005
R1436 VSS.n312 VSS.n184 5.2005
R1437 VSS.n324 VSS.n323 5.2005
R1438 VSS.n324 VSS.n183 5.2005
R1439 VSS.n325 VSS.n171 5.2005
R1440 VSS.n326 VSS.n325 5.2005
R1441 VSS.n1053 VSS.n41 5.2005
R1442 VSS.n327 VSS.n41 5.2005
R1443 VSS.n330 VSS.n329 5.2005
R1444 VSS.n329 VSS.n328 5.2005
R1445 VSS.n1048 VSS.n1047 5.2005
R1446 VSS.n1049 VSS.n1048 5.2005
R1447 VSS.n46 VSS.n45 5.2005
R1448 VSS.n1045 VSS.n1044 5.2005
R1449 VSS.n1043 VSS.n51 5.2005
R1450 VSS.n1042 VSS.n1041 5.2005
R1451 VSS.n1040 VSS.n1039 5.2005
R1452 VSS.n1038 VSS.n1037 5.2005
R1453 VSS.n1036 VSS.n1035 5.2005
R1454 VSS.n182 VSS.n52 5.2005
R1455 VSS.n1018 VSS.n1017 5.2005
R1456 VSS.n58 VSS.n55 5.2005
R1457 VSS.n1003 VSS.n1002 5.2005
R1458 VSS.n1005 VSS.n1004 5.2005
R1459 VSS.n1007 VSS.n1006 5.2005
R1460 VSS.n1009 VSS.n1008 5.2005
R1461 VSS.n1015 VSS.n62 5.2005
R1462 VSS.n1010 VSS.n62 5.2005
R1463 VSS.n1011 VSS.n63 5.2005
R1464 VSS.n1013 VSS.n1012 5.2005
R1465 VSS.n280 VSS.n154 5.2005
R1466 VSS.n154 VSS.n152 5.2005
R1467 VSS.n359 VSS.n172 5.2005
R1468 VSS.n215 VSS.n172 5.2005
R1469 VSS.n275 VSS.n218 5.2005
R1470 VSS.n218 VSS.n217 5.2005
R1471 VSS.n353 VSS.n180 5.2005
R1472 VSS.n216 VSS.n180 5.2005
R1473 VSS.n148 VSS.n47 5.2005
R1474 VSS.n148 VSS.n147 5.2005
R1475 VSS.n389 VSS.n33 5.2005
R1476 VSS.n390 VSS.n389 5.2005
R1477 VSS.n347 VSS.n335 5.2005
R1478 VSS.n345 VSS.n344 5.2005
R1479 VSS.n343 VSS.n336 5.2005
R1480 VSS.n342 VSS.n341 5.2005
R1481 VSS.n340 VSS.n337 5.2005
R1482 VSS.n150 VSS.n149 5.2005
R1483 VSS.n386 VSS.n385 5.2005
R1484 VSS.n388 VSS.n146 5.2005
R1485 VSS.n375 VSS.n374 5.2005
R1486 VSS.n376 VSS.n375 5.2005
R1487 VSS.n153 VSS.n151 5.2005
R1488 VSS.n364 VSS.n363 5.2005
R1489 VSS.n366 VSS.n365 5.2005
R1490 VSS.n368 VSS.n367 5.2005
R1491 VSS.n374 VSS.n166 5.2005
R1492 VSS.n369 VSS.n166 5.2005
R1493 VSS.n370 VSS.n167 5.2005
R1494 VSS.n372 VSS.n371 5.2005
R1495 VSS.n280 VSS.n168 5.2005
R1496 VSS.n362 VSS.n168 5.2005
R1497 VSS.n360 VSS.n359 5.2005
R1498 VSS.n361 VSS.n360 5.2005
R1499 VSS.n275 VSS.n170 5.2005
R1500 VSS.n170 VSS.n169 5.2005
R1501 VSS.n353 VSS.n352 5.2005
R1502 VSS.n352 VSS.n351 5.2005
R1503 VSS.n334 VSS.n47 5.2005
R1504 VSS.n350 VSS.n334 5.2005
R1505 VSS.n348 VSS.n33 5.2005
R1506 VSS.n349 VSS.n348 5.2005
R1507 VSS.n280 VSS.n186 5.2005
R1508 VSS.n255 VSS.n186 5.2005
R1509 VSS.n359 VSS.n173 5.2005
R1510 VSS.n219 VSS.n173 5.2005
R1511 VSS.n275 VSS.n274 5.2005
R1512 VSS.n274 VSS.n273 5.2005
R1513 VSS.n353 VSS.n181 5.2005
R1514 VSS.n272 VSS.n181 5.2005
R1515 VSS.n270 VSS.n47 5.2005
R1516 VSS.n271 VSS.n270 5.2005
R1517 VSS.n269 VSS.n33 5.2005
R1518 VSS.n269 VSS.n220 5.2005
R1519 VSS.n228 VSS.n227 5.2005
R1520 VSS.n230 VSS.n224 5.2005
R1521 VSS.n233 VSS.n232 5.2005
R1522 VSS.n234 VSS.n223 5.2005
R1523 VSS.n236 VSS.n235 5.2005
R1524 VSS.n238 VSS.n222 5.2005
R1525 VSS.n240 VSS.n239 5.2005
R1526 VSS.n268 VSS.n267 5.2005
R1527 VSS.n257 VSS.n256 5.2005
R1528 VSS.n254 VSS.n253 5.2005
R1529 VSS.n252 VSS.n251 5.2005
R1530 VSS.n250 VSS.n249 5.2005
R1531 VSS.n248 VSS.n247 5.2005
R1532 VSS.n246 VSS.n245 5.2005
R1533 VSS.n244 VSS.n243 5.2005
R1534 VSS.n242 VSS.n241 5.2005
R1535 VSS.n280 VSS.n175 5.2005
R1536 VSS.n177 VSS.n175 5.2005
R1537 VSS.n359 VSS.n358 5.2005
R1538 VSS.n358 VSS.n357 5.2005
R1539 VSS.n275 VSS.n176 5.2005
R1540 VSS.n356 VSS.n176 5.2005
R1541 VSS.n354 VSS.n353 5.2005
R1542 VSS.n355 VSS.n354 5.2005
R1543 VSS.n179 VSS.n47 5.2005
R1544 VSS.n179 VSS.n178 5.2005
R1545 VSS.n225 VSS.n33 5.2005
R1546 VSS.n226 VSS.n225 5.2005
R1547 VSS.n187 VSS.n185 5.2005
R1548 VSS.n211 VSS.n187 5.2005
R1549 VSS.n278 VSS.n214 5.2005
R1550 VSS.n214 VSS.n213 5.2005
R1551 VSS.n1054 VSS.n40 5.2005
R1552 VSS.n212 VSS.n40 5.2005
R1553 VSS.n331 VSS.n32 5.2005
R1554 VSS.n32 VSS.n31 5.2005
R1555 VSS.n1061 VSS.n1060 5.2005
R1556 VSS.n1062 VSS.n1061 5.2005
R1557 VSS.n35 VSS.n30 5.2005
R1558 VSS.n1063 VSS.n30 5.2005
R1559 VSS.n1067 VSS.n1065 5.2005
R1560 VSS.n1065 VSS.n1064 5.2005
R1561 VSS.n1066 VSS.n21 5.2005
R1562 VSS.n21 VSS.n20 5.2005
R1563 VSS.n1075 VSS.n1074 5.2005
R1564 VSS.n1076 VSS.n1075 5.2005
R1565 VSS.n25 VSS.n19 5.2005
R1566 VSS.n1077 VSS.n19 5.2005
R1567 VSS.n1079 VSS.n6 5.2005
R1568 VSS.n1079 VSS.n1078 5.2005
R1569 VSS.n1101 VSS.n1100 5.2005
R1570 VSS.n1100 VSS.n1099 5.2005
R1571 VSS.n1098 VSS.n12 5.2005
R1572 VSS.n1097 VSS.n1096 5.2005
R1573 VSS.n1095 VSS.n1094 5.2005
R1574 VSS.n1093 VSS.n1092 5.2005
R1575 VSS.n1091 VSS.n1090 5.2005
R1576 VSS.n1089 VSS.n1088 5.2005
R1577 VSS.n1087 VSS.n1086 5.2005
R1578 VSS.n1081 VSS.n1080 5.2005
R1579 VSS.n374 VSS.n155 5.2005
R1580 VSS.n210 VSS.n155 5.2005
R1581 VSS.n209 VSS.n208 5.2005
R1582 VSS.n203 VSS.n202 5.2005
R1583 VSS.n201 VSS.n200 5.2005
R1584 VSS.n199 VSS.n198 5.2005
R1585 VSS.n197 VSS.n196 5.2005
R1586 VSS.n195 VSS.n194 5.2005
R1587 VSS.n193 VSS.n192 5.2005
R1588 VSS.n191 VSS.n190 5.2005
R1589 VSS.n189 VSS.n185 5.2005
R1590 VSS.n189 VSS.n188 5.2005
R1591 VSS.n278 VSS.n39 5.2005
R1592 VSS.n39 VSS.n38 5.2005
R1593 VSS.n1055 VSS.n1054 5.2005
R1594 VSS.n1056 VSS.n1055 5.2005
R1595 VSS.n331 VSS.n37 5.2005
R1596 VSS.n1057 VSS.n37 5.2005
R1597 VSS.n1060 VSS.n1059 5.2005
R1598 VSS.n1059 VSS.n1058 5.2005
R1599 VSS.n35 VSS.n28 5.2005
R1600 VSS.n28 VSS.n27 5.2005
R1601 VSS.n1068 VSS.n1067 5.2005
R1602 VSS.n1069 VSS.n1068 5.2005
R1603 VSS.n1066 VSS.n23 5.2005
R1604 VSS.n1070 VSS.n23 5.2005
R1605 VSS.n1074 VSS.n1073 5.2005
R1606 VSS.n1073 VSS.n1072 5.2005
R1607 VSS.n26 VSS.n25 5.2005
R1608 VSS.n1071 VSS.n26 5.2005
R1609 VSS.n11 VSS.n6 5.2005
R1610 VSS.n13 VSS.n11 5.2005
R1611 VSS.n1711 VSS.n1710 5.2005
R1612 VSS.n1711 VSS.n1178 5.2005
R1613 VSS.n1487 VSS.n1179 5.2005
R1614 VSS.n1342 VSS.n1179 5.2005
R1615 VSS.n1704 VSS.n1191 5.2005
R1616 VSS.n1343 VSS.n1191 5.2005
R1617 VSS.n1637 VSS.n1295 5.2005
R1618 VSS.n1344 VSS.n1295 5.2005
R1619 VSS.n1698 VSS.n1204 5.2005
R1620 VSS.n1345 VSS.n1204 5.2005
R1621 VSS.n1631 VSS.n1304 5.2005
R1622 VSS.n1346 VSS.n1304 5.2005
R1623 VSS.n1692 VSS.n1217 5.2005
R1624 VSS.n1347 VSS.n1217 5.2005
R1625 VSS.n1625 VSS.n1350 5.2005
R1626 VSS.n1350 VSS.n1349 5.2005
R1627 VSS.n1686 VSS.n1227 5.2005
R1628 VSS.n1348 VSS.n1227 5.2005
R1629 VSS.n1236 VSS.n1226 5.2005
R1630 VSS.n1226 VSS.n1225 5.2005
R1631 VSS.n1257 VSS.n1256 5.2005
R1632 VSS.n1258 VSS.n1254 5.2005
R1633 VSS.n1262 VSS.n1261 5.2005
R1634 VSS.n1264 VSS.n1253 5.2005
R1635 VSS.n1267 VSS.n1266 5.2005
R1636 VSS.n1268 VSS.n1252 5.2005
R1637 VSS.n1270 VSS.n1269 5.2005
R1638 VSS.n1273 VSS.n1272 5.2005
R1639 VSS.n1713 VSS.n1712 5.2005
R1640 VSS.n1715 VSS.n1714 5.2005
R1641 VSS.n1717 VSS.n1716 5.2005
R1642 VSS.n1719 VSS.n1718 5.2005
R1643 VSS.n1721 VSS.n1720 5.2005
R1644 VSS.n1723 VSS.n1722 5.2005
R1645 VSS.n1731 VSS.n1173 5.2005
R1646 VSS.n1726 VSS.n1173 5.2005
R1647 VSS.n1727 VSS.n1174 5.2005
R1648 VSS.n1729 VSS.n1728 5.2005
R1649 VSS.n1710 VSS.n1175 5.2005
R1650 VSS.n1176 VSS.n1175 5.2005
R1651 VSS.n1487 VSS.n1198 5.2005
R1652 VSS.n1200 VSS.n1198 5.2005
R1653 VSS.n1704 VSS.n1703 5.2005
R1654 VSS.n1703 VSS.n1702 5.2005
R1655 VSS.n1637 VSS.n1199 5.2005
R1656 VSS.n1701 VSS.n1199 5.2005
R1657 VSS.n1699 VSS.n1698 5.2005
R1658 VSS.n1700 VSS.n1699 5.2005
R1659 VSS.n1631 VSS.n1202 5.2005
R1660 VSS.n1202 VSS.n1201 5.2005
R1661 VSS.n1692 VSS.n1691 5.2005
R1662 VSS.n1691 VSS.n1690 5.2005
R1663 VSS.n1625 VSS.n1224 5.2005
R1664 VSS.n1689 VSS.n1224 5.2005
R1665 VSS.n1687 VSS.n1686 5.2005
R1666 VSS.n1688 VSS.n1687 5.2005
R1667 VSS.n778 VSS.n777 5.2005
R1668 VSS.n779 VSS.n778 5.2005
R1669 VSS.n803 VSS.n485 5.2005
R1670 VSS.n525 VSS.n485 5.2005
R1671 VSS.n523 VSS.n483 5.2005
R1672 VSS.n524 VSS.n523 5.2005
R1673 VSS.n855 VSS.n429 5.2005
R1674 VSS.n522 VSS.n429 5.2005
R1675 VSS.n868 VSS.n403 5.2005
R1676 VSS.n521 VSS.n403 5.2005
R1677 VSS.n849 VSS.n439 5.2005
R1678 VSS.n520 VSS.n439 5.2005
R1679 VSS.n862 VSS.n418 5.2005
R1680 VSS.n519 VSS.n418 5.2005
R1681 VSS.n843 VSS.n129 5.2005
R1682 VSS.n518 VSS.n129 5.2005
R1683 VSS.n902 VSS.n901 5.2005
R1684 VSS.n902 VSS.n130 5.2005
R1685 VSS.n924 VSS.n923 5.2005
R1686 VSS.n923 VSS.n922 5.2005
R1687 VSS.n921 VSS.n124 5.2005
R1688 VSS.n920 VSS.n919 5.2005
R1689 VSS.n918 VSS.n917 5.2005
R1690 VSS.n916 VSS.n915 5.2005
R1691 VSS.n914 VSS.n913 5.2005
R1692 VSS.n912 VSS.n911 5.2005
R1693 VSS.n910 VSS.n909 5.2005
R1694 VSS.n904 VSS.n903 5.2005
R1695 VSS.n795 VSS.n515 5.2005
R1696 VSS.n780 VSS.n515 5.2005
R1697 VSS.n782 VSS.n781 5.2005
R1698 VSS.n786 VSS.n785 5.2005
R1699 VSS.n795 VSS.n497 5.2005
R1700 VSS.n787 VSS.n497 5.2005
R1701 VSS.n789 VSS.n788 5.2005
R1702 VSS.n790 VSS.n517 5.2005
R1703 VSS.n795 VSS.n794 5.2005
R1704 VSS.n794 VSS.n793 5.2005
R1705 VSS.n495 VSS.n494 5.2005
R1706 VSS.n798 VSS.n797 5.2005
R1707 VSS.n777 VSS.n492 5.2005
R1708 VSS.n799 VSS.n492 5.2005
R1709 VSS.n803 VSS.n802 5.2005
R1710 VSS.n802 VSS.n801 5.2005
R1711 VSS.n493 VSS.n483 5.2005
R1712 VSS.n800 VSS.n493 5.2005
R1713 VSS.n855 VSS.n412 5.2005
R1714 VSS.n414 VSS.n412 5.2005
R1715 VSS.n868 VSS.n867 5.2005
R1716 VSS.n867 VSS.n866 5.2005
R1717 VSS.n849 VSS.n413 5.2005
R1718 VSS.n865 VSS.n413 5.2005
R1719 VSS.n863 VSS.n862 5.2005
R1720 VSS.n864 VSS.n863 5.2005
R1721 VSS.n843 VSS.n416 5.2005
R1722 VSS.n416 VSS.n415 5.2005
R1723 VSS.n901 VSS.n123 5.2005
R1724 VSS.n125 VSS.n123 5.2005
R1725 VSS.n1710 VSS.n1180 5.2005
R1726 VSS.n1408 VSS.n1180 5.2005
R1727 VSS.n1487 VSS.n1416 5.2005
R1728 VSS.n1416 VSS.n1415 5.2005
R1729 VSS.n1704 VSS.n1192 5.2005
R1730 VSS.n1414 VSS.n1192 5.2005
R1731 VSS.n1637 VSS.n1296 5.2005
R1732 VSS.n1413 VSS.n1296 5.2005
R1733 VSS.n1698 VSS.n1205 5.2005
R1734 VSS.n1412 VSS.n1205 5.2005
R1735 VSS.n1631 VSS.n1305 5.2005
R1736 VSS.n1411 VSS.n1305 5.2005
R1737 VSS.n1692 VSS.n1218 5.2005
R1738 VSS.n1410 VSS.n1218 5.2005
R1739 VSS.n1625 VSS.n1351 5.2005
R1740 VSS.n1409 VSS.n1351 5.2005
R1741 VSS.n1686 VSS.n1228 5.2005
R1742 VSS.n1247 VSS.n1228 5.2005
R1743 VSS.n1236 VSS.n1234 5.2005
R1744 VSS.n1683 VSS.n1234 5.2005
R1745 VSS.n1682 VSS.n1681 5.2005
R1746 VSS.n1679 VSS.n1235 5.2005
R1747 VSS.n1678 VSS.n1239 5.2005
R1748 VSS.n1676 VSS.n1675 5.2005
R1749 VSS.n1674 VSS.n1240 5.2005
R1750 VSS.n1673 VSS.n1672 5.2005
R1751 VSS.n1671 VSS.n1241 5.2005
R1752 VSS.n1669 VSS.n1668 5.2005
R1753 VSS.n1731 VSS.n1159 5.2005
R1754 VSS.n1407 VSS.n1159 5.2005
R1755 VSS.n1406 VSS.n1405 5.2005
R1756 VSS.n1403 VSS.n1402 5.2005
R1757 VSS.n1401 VSS.n1400 5.2005
R1758 VSS.n1399 VSS.n1398 5.2005
R1759 VSS.n1397 VSS.n1396 5.2005
R1760 VSS.n1393 VSS.n1392 5.2005
R1761 VSS.n1391 VSS.n1390 5.2005
R1762 VSS.n1187 VSS.n1185 5.2005
R1763 VSS.n1710 VSS.n1709 5.2005
R1764 VSS.n1709 VSS.n1708 5.2005
R1765 VSS.n1487 VSS.n1186 5.2005
R1766 VSS.n1707 VSS.n1186 5.2005
R1767 VSS.n1705 VSS.n1704 5.2005
R1768 VSS.n1706 VSS.n1705 5.2005
R1769 VSS.n1637 VSS.n1189 5.2005
R1770 VSS.n1189 VSS.n1188 5.2005
R1771 VSS.n1698 VSS.n1697 5.2005
R1772 VSS.n1697 VSS.n1696 5.2005
R1773 VSS.n1631 VSS.n1213 5.2005
R1774 VSS.n1695 VSS.n1213 5.2005
R1775 VSS.n1693 VSS.n1692 5.2005
R1776 VSS.n1694 VSS.n1693 5.2005
R1777 VSS.n1625 VSS.n1215 5.2005
R1778 VSS.n1215 VSS.n1214 5.2005
R1779 VSS.n1686 VSS.n1685 5.2005
R1780 VSS.n1685 VSS.n1684 5.2005
R1781 VSS.n777 VSS.n526 5.2005
R1782 VSS.n753 VSS.n526 5.2005
R1783 VSS.n803 VSS.n486 5.2005
R1784 VSS.n752 VSS.n486 5.2005
R1785 VSS.n750 VSS.n483 5.2005
R1786 VSS.n751 VSS.n750 5.2005
R1787 VSS.n855 VSS.n430 5.2005
R1788 VSS.n749 VSS.n430 5.2005
R1789 VSS.n868 VSS.n404 5.2005
R1790 VSS.n748 VSS.n404 5.2005
R1791 VSS.n849 VSS.n440 5.2005
R1792 VSS.n747 VSS.n440 5.2005
R1793 VSS.n862 VSS.n419 5.2005
R1794 VSS.n746 VSS.n419 5.2005
R1795 VSS.n843 VSS.n472 5.2005
R1796 VSS.n745 VSS.n472 5.2005
R1797 VSS.n901 VSS.n131 5.2005
R1798 VSS.n141 VSS.n131 5.2005
R1799 VSS.n924 VSS.n104 5.2005
R1800 VSS.n898 VSS.n104 5.2005
R1801 VSS.n897 VSS.n896 5.2005
R1802 VSS.n895 VSS.n894 5.2005
R1803 VSS.n893 VSS.n892 5.2005
R1804 VSS.n891 VSS.n890 5.2005
R1805 VSS.n889 VSS.n888 5.2005
R1806 VSS.n887 VSS.n886 5.2005
R1807 VSS.n885 VSS.n884 5.2005
R1808 VSS.n879 VSS.n878 5.2005
R1809 VSS.n795 VSS.n503 5.2005
R1810 VSS.n754 VSS.n503 5.2005
R1811 VSS.n756 VSS.n755 5.2005
R1812 VSS.n760 VSS.n759 5.2005
R1813 VSS.n762 VSS.n761 5.2005
R1814 VSS.n764 VSS.n763 5.2005
R1815 VSS.n766 VSS.n765 5.2005
R1816 VSS.n770 VSS.n769 5.2005
R1817 VSS.n772 VSS.n771 5.2005
R1818 VSS.n773 VSS.n744 5.2005
R1819 VSS.n777 VSS.n776 5.2005
R1820 VSS.n776 VSS.n775 5.2005
R1821 VSS.n803 VSS.n491 5.2005
R1822 VSS.n774 VSS.n491 5.2005
R1823 VSS.n483 VSS.n427 5.2005
R1824 VSS.n427 VSS.n426 5.2005
R1825 VSS.n856 VSS.n855 5.2005
R1826 VSS.n857 VSS.n856 5.2005
R1827 VSS.n868 VSS.n411 5.2005
R1828 VSS.n858 VSS.n411 5.2005
R1829 VSS.n849 VSS.n425 5.2005
R1830 VSS.n859 VSS.n425 5.2005
R1831 VSS.n862 VSS.n861 5.2005
R1832 VSS.n861 VSS.n860 5.2005
R1833 VSS.n843 VSS.n137 5.2005
R1834 VSS.n138 VSS.n137 5.2005
R1835 VSS.n901 VSS.n900 5.2005
R1836 VSS.n900 VSS.n899 5.2005
R1837 VSS.n1710 VSS.n1181 5.2005
R1838 VSS.n1464 VSS.n1181 5.2005
R1839 VSS.n1487 VSS.n1417 5.2005
R1840 VSS.n1463 VSS.n1417 5.2005
R1841 VSS.n1704 VSS.n1193 5.2005
R1842 VSS.n1462 VSS.n1193 5.2005
R1843 VSS.n1637 VSS.n1297 5.2005
R1844 VSS.n1461 VSS.n1297 5.2005
R1845 VSS.n1698 VSS.n1206 5.2005
R1846 VSS.n1460 VSS.n1206 5.2005
R1847 VSS.n1631 VSS.n1306 5.2005
R1848 VSS.n1459 VSS.n1306 5.2005
R1849 VSS.n1692 VSS.n1219 5.2005
R1850 VSS.n1458 VSS.n1219 5.2005
R1851 VSS.n1625 VSS.n1352 5.2005
R1852 VSS.n1457 VSS.n1352 5.2005
R1853 VSS.n1686 VSS.n1229 5.2005
R1854 VSS.n1456 VSS.n1229 5.2005
R1855 VSS.n1620 VSS.n1236 5.2005
R1856 VSS.n1621 VSS.n1620 5.2005
R1857 VSS.n1619 VSS.n1594 5.2005
R1858 VSS.n1617 VSS.n1616 5.2005
R1859 VSS.n1613 VSS.n1595 5.2005
R1860 VSS.n1612 VSS.n1611 5.2005
R1861 VSS.n1610 VSS.n1596 5.2005
R1862 VSS.n1608 VSS.n1607 5.2005
R1863 VSS.n1606 VSS.n1598 5.2005
R1864 VSS.n1601 VSS.n1600 5.2005
R1865 VSS.n1731 VSS.n1166 5.2005
R1866 VSS.n1465 VSS.n1166 5.2005
R1867 VSS.n1467 VSS.n1466 5.2005
R1868 VSS.n1469 VSS.n1468 5.2005
R1869 VSS.n1471 VSS.n1470 5.2005
R1870 VSS.n1473 VSS.n1472 5.2005
R1871 VSS.n1475 VSS.n1474 5.2005
R1872 VSS.n1479 VSS.n1478 5.2005
R1873 VSS.n1481 VSS.n1480 5.2005
R1874 VSS.n1483 VSS.n1482 5.2005
R1875 VSS.n1710 VSS.n1184 5.2005
R1876 VSS.n1484 VSS.n1184 5.2005
R1877 VSS.n1487 VSS.n1486 5.2005
R1878 VSS.n1486 VSS.n1485 5.2005
R1879 VSS.n1704 VSS.n1197 5.2005
R1880 VSS.n1302 VSS.n1197 5.2005
R1881 VSS.n1637 VSS.n1636 5.2005
R1882 VSS.n1636 VSS.n1635 5.2005
R1883 VSS.n1698 VSS.n1212 5.2005
R1884 VSS.n1634 VSS.n1212 5.2005
R1885 VSS.n1632 VSS.n1631 5.2005
R1886 VSS.n1633 VSS.n1632 5.2005
R1887 VSS.n1692 VSS.n1223 5.2005
R1888 VSS.n1303 VSS.n1223 5.2005
R1889 VSS.n1625 VSS.n1624 5.2005
R1890 VSS.n1624 VSS.n1623 5.2005
R1891 VSS.n1686 VSS.n1233 5.2005
R1892 VSS.n1622 VSS.n1233 5.2005
R1893 VSS.n777 VSS.n527 5.2005
R1894 VSS.n720 VSS.n527 5.2005
R1895 VSS.n803 VSS.n487 5.2005
R1896 VSS.n719 VSS.n487 5.2005
R1897 VSS.n717 VSS.n483 5.2005
R1898 VSS.n718 VSS.n717 5.2005
R1899 VSS.n855 VSS.n431 5.2005
R1900 VSS.n716 VSS.n431 5.2005
R1901 VSS.n868 VSS.n405 5.2005
R1902 VSS.n715 VSS.n405 5.2005
R1903 VSS.n849 VSS.n441 5.2005
R1904 VSS.n714 VSS.n441 5.2005
R1905 VSS.n862 VSS.n420 5.2005
R1906 VSS.n713 VSS.n420 5.2005
R1907 VSS.n843 VSS.n473 5.2005
R1908 VSS.n712 VSS.n473 5.2005
R1909 VSS.n901 VSS.n132 5.2005
R1910 VSS.n711 VSS.n132 5.2005
R1911 VSS.n924 VSS.n118 5.2005
R1912 VSS.n839 VSS.n118 5.2005
R1913 VSS.n838 VSS.n837 5.2005
R1914 VSS.n836 VSS.n835 5.2005
R1915 VSS.n834 VSS.n833 5.2005
R1916 VSS.n832 VSS.n831 5.2005
R1917 VSS.n830 VSS.n829 5.2005
R1918 VSS.n828 VSS.n827 5.2005
R1919 VSS.n826 VSS.n825 5.2005
R1920 VSS.n820 VSS.n819 5.2005
R1921 VSS.n795 VSS.n510 5.2005
R1922 VSS.n721 VSS.n510 5.2005
R1923 VSS.n723 VSS.n722 5.2005
R1924 VSS.n727 VSS.n726 5.2005
R1925 VSS.n729 VSS.n728 5.2005
R1926 VSS.n731 VSS.n730 5.2005
R1927 VSS.n733 VSS.n732 5.2005
R1928 VSS.n737 VSS.n736 5.2005
R1929 VSS.n739 VSS.n738 5.2005
R1930 VSS.n740 VSS.n710 5.2005
R1931 VSS.n777 VSS.n743 5.2005
R1932 VSS.n743 VSS.n742 5.2005
R1933 VSS.n803 VSS.n490 5.2005
R1934 VSS.n741 VSS.n490 5.2005
R1935 VSS.n483 VSS.n436 5.2005
R1936 VSS.n437 VSS.n436 5.2005
R1937 VSS.n855 VSS.n854 5.2005
R1938 VSS.n854 VSS.n853 5.2005
R1939 VSS.n868 VSS.n410 5.2005
R1940 VSS.n852 VSS.n410 5.2005
R1941 VSS.n850 VSS.n849 5.2005
R1942 VSS.n851 VSS.n850 5.2005
R1943 VSS.n862 VSS.n424 5.2005
R1944 VSS.n438 VSS.n424 5.2005
R1945 VSS.n843 VSS.n842 5.2005
R1946 VSS.n842 VSS.n841 5.2005
R1947 VSS.n901 VSS.n136 5.2005
R1948 VSS.n840 VSS.n136 5.2005
R1949 VSS.n1710 VSS.n1182 5.2005
R1950 VSS.n1430 VSS.n1182 5.2005
R1951 VSS.n1487 VSS.n1418 5.2005
R1952 VSS.n1429 VSS.n1418 5.2005
R1953 VSS.n1704 VSS.n1194 5.2005
R1954 VSS.n1428 VSS.n1194 5.2005
R1955 VSS.n1637 VSS.n1298 5.2005
R1956 VSS.n1427 VSS.n1298 5.2005
R1957 VSS.n1698 VSS.n1207 5.2005
R1958 VSS.n1426 VSS.n1207 5.2005
R1959 VSS.n1631 VSS.n1307 5.2005
R1960 VSS.n1425 VSS.n1307 5.2005
R1961 VSS.n1692 VSS.n1220 5.2005
R1962 VSS.n1424 VSS.n1220 5.2005
R1963 VSS.n1625 VSS.n1353 5.2005
R1964 VSS.n1423 VSS.n1353 5.2005
R1965 VSS.n1686 VSS.n1230 5.2005
R1966 VSS.n1422 VSS.n1230 5.2005
R1967 VSS.n1336 VSS.n1236 5.2005
R1968 VSS.n1337 VSS.n1336 5.2005
R1969 VSS.n1335 VSS.n1310 5.2005
R1970 VSS.n1333 VSS.n1332 5.2005
R1971 VSS.n1329 VSS.n1311 5.2005
R1972 VSS.n1328 VSS.n1327 5.2005
R1973 VSS.n1326 VSS.n1312 5.2005
R1974 VSS.n1324 VSS.n1323 5.2005
R1975 VSS.n1322 VSS.n1314 5.2005
R1976 VSS.n1317 VSS.n1316 5.2005
R1977 VSS.n1731 VSS.n1164 5.2005
R1978 VSS.n1431 VSS.n1164 5.2005
R1979 VSS.n1433 VSS.n1432 5.2005
R1980 VSS.n1435 VSS.n1434 5.2005
R1981 VSS.n1437 VSS.n1436 5.2005
R1982 VSS.n1439 VSS.n1438 5.2005
R1983 VSS.n1441 VSS.n1440 5.2005
R1984 VSS.n1445 VSS.n1444 5.2005
R1985 VSS.n1447 VSS.n1446 5.2005
R1986 VSS.n1449 VSS.n1448 5.2005
R1987 VSS.n1710 VSS.n1183 5.2005
R1988 VSS.n1450 VSS.n1183 5.2005
R1989 VSS.n1487 VSS.n1454 5.2005
R1990 VSS.n1454 VSS.n1453 5.2005
R1991 VSS.n1704 VSS.n1196 5.2005
R1992 VSS.n1452 VSS.n1196 5.2005
R1993 VSS.n1637 VSS.n1301 5.2005
R1994 VSS.n1451 VSS.n1301 5.2005
R1995 VSS.n1698 VSS.n1211 5.2005
R1996 VSS.n1309 VSS.n1211 5.2005
R1997 VSS.n1631 VSS.n1630 5.2005
R1998 VSS.n1630 VSS.n1629 5.2005
R1999 VSS.n1692 VSS.n1222 5.2005
R2000 VSS.n1628 VSS.n1222 5.2005
R2001 VSS.n1626 VSS.n1625 5.2005
R2002 VSS.n1627 VSS.n1626 5.2005
R2003 VSS.n1686 VSS.n1232 5.2005
R2004 VSS.n1338 VSS.n1232 5.2005
R2005 VSS.n777 VSS.n528 5.2005
R2006 VSS.n683 VSS.n528 5.2005
R2007 VSS.n803 VSS.n488 5.2005
R2008 VSS.n682 VSS.n488 5.2005
R2009 VSS.n680 VSS.n483 5.2005
R2010 VSS.n681 VSS.n680 5.2005
R2011 VSS.n855 VSS.n432 5.2005
R2012 VSS.n679 VSS.n432 5.2005
R2013 VSS.n868 VSS.n406 5.2005
R2014 VSS.n678 VSS.n406 5.2005
R2015 VSS.n849 VSS.n442 5.2005
R2016 VSS.n677 VSS.n442 5.2005
R2017 VSS.n862 VSS.n421 5.2005
R2018 VSS.n676 VSS.n421 5.2005
R2019 VSS.n843 VSS.n474 5.2005
R2020 VSS.n675 VSS.n474 5.2005
R2021 VSS.n901 VSS.n133 5.2005
R2022 VSS.n674 VSS.n133 5.2005
R2023 VSS.n924 VSS.n109 5.2005
R2024 VSS.n467 VSS.n109 5.2005
R2025 VSS.n466 VSS.n465 5.2005
R2026 VSS.n464 VSS.n463 5.2005
R2027 VSS.n462 VSS.n461 5.2005
R2028 VSS.n460 VSS.n459 5.2005
R2029 VSS.n458 VSS.n457 5.2005
R2030 VSS.n456 VSS.n455 5.2005
R2031 VSS.n454 VSS.n453 5.2005
R2032 VSS.n448 VSS.n447 5.2005
R2033 VSS.n795 VSS.n508 5.2005
R2034 VSS.n684 VSS.n508 5.2005
R2035 VSS.n686 VSS.n685 5.2005
R2036 VSS.n690 VSS.n689 5.2005
R2037 VSS.n692 VSS.n691 5.2005
R2038 VSS.n694 VSS.n693 5.2005
R2039 VSS.n696 VSS.n695 5.2005
R2040 VSS.n700 VSS.n699 5.2005
R2041 VSS.n702 VSS.n701 5.2005
R2042 VSS.n703 VSS.n673 5.2005
R2043 VSS.n777 VSS.n709 5.2005
R2044 VSS.n709 VSS.n708 5.2005
R2045 VSS.n803 VSS.n489 5.2005
R2046 VSS.n707 VSS.n489 5.2005
R2047 VSS.n705 VSS.n483 5.2005
R2048 VSS.n706 VSS.n705 5.2005
R2049 VSS.n855 VSS.n435 5.2005
R2050 VSS.n704 VSS.n435 5.2005
R2051 VSS.n868 VSS.n409 5.2005
R2052 VSS.n444 VSS.n409 5.2005
R2053 VSS.n849 VSS.n848 5.2005
R2054 VSS.n848 VSS.n847 5.2005
R2055 VSS.n862 VSS.n423 5.2005
R2056 VSS.n846 VSS.n423 5.2005
R2057 VSS.n844 VSS.n843 5.2005
R2058 VSS.n845 VSS.n844 5.2005
R2059 VSS.n901 VSS.n135 5.2005
R2060 VSS.n468 VSS.n135 5.2005
R2061 VSS.n1640 VSS.n1639 5.2005
R2062 VSS.n1640 VSS.n1294 5.2005
R2063 VSS.t130 VSS.n1641 5.2005
R2064 VSS.n1641 VSS.n1277 5.2005
R2065 VSS.n1698 VSS.n1208 5.2005
R2066 VSS.n1660 VSS.n1208 5.2005
R2067 VSS.n1658 VSS.t215 5.2005
R2068 VSS.n1659 VSS.n1658 5.2005
R2069 VSS.n1522 VSS.n1279 5.2005
R2070 VSS.n1279 VSS.n1278 5.2005
R2071 VSS.n1654 VSS.n1653 5.2005
R2072 VSS.n1651 VSS.n1645 5.2005
R2073 VSS.n1650 VSS.n1646 5.2005
R2074 VSS.n1648 VSS.n1647 5.2005
R2075 VSS.n1293 VSS.n1284 5.2005
R2076 VSS.n1292 VSS.n1291 5.2005
R2077 VSS.n1289 VSS.n1285 5.2005
R2078 VSS.n1287 VSS.n1286 5.2005
R2079 VSS.n1639 VSS.n1283 5.2005
R2080 VSS.n1283 VSS.n1282 5.2005
R2081 VSS.n1642 VSS.t130 5.2005
R2082 VSS.n1643 VSS.n1642 5.2005
R2083 VSS.n1698 VSS.n1210 5.2005
R2084 VSS.n1644 VSS.n1210 5.2005
R2085 VSS.t215 VSS.n1657 5.2005
R2086 VSS.n1657 VSS.n1656 5.2005
R2087 VSS.n1522 VSS.n1281 5.2005
R2088 VSS.n1655 VSS.n1281 5.2005
R2089 VSS.n645 VSS.n644 5.2005
R2090 VSS.n644 VSS.n643 5.2005
R2091 VSS.t220 VSS.n400 5.2005
R2092 VSS.n400 VSS.n398 5.2005
R2093 VSS.n869 VSS.n868 5.2005
R2094 VSS.n870 VSS.n869 5.2005
R2095 VSS.t218 VSS.n401 5.2005
R2096 VSS.n401 VSS.n399 5.2005
R2097 VSS.n663 VSS.n627 5.2005
R2098 VSS.n653 VSS.n627 5.2005
R2099 VSS.n660 VSS.n630 5.2005
R2100 VSS.n659 VSS.n658 5.2005
R2101 VSS.n657 VSS.n651 5.2005
R2102 VSS.n655 VSS.n654 5.2005
R2103 VSS.n642 VSS.n633 5.2005
R2104 VSS.n641 VSS.n640 5.2005
R2105 VSS.n636 VSS.n635 5.2005
R2106 VSS.n634 VSS.n632 5.2005
R2107 VSS.n646 VSS.n645 5.2005
R2108 VSS.n646 VSS.n631 5.2005
R2109 VSS.n647 VSS.t220 5.2005
R2110 VSS.n648 VSS.n647 5.2005
R2111 VSS.n868 VSS.n408 5.2005
R2112 VSS.n649 VSS.n408 5.2005
R2113 VSS.n629 VSS.t218 5.2005
R2114 VSS.n650 VSS.n629 5.2005
R2115 VSS.n663 VSS.n662 5.2005
R2116 VSS.n662 VSS.n661 5.2005
R2117 VSS.n1750 VSS.n1749 5.2005
R2118 VSS.n1751 VSS.n1750 5.2005
R2119 VSS.n1103 VSS.n5 5.2005
R2120 VSS.n5 VSS.n3 5.2005
R2121 VSS.n1743 VSS.n1149 5.2005
R2122 VSS.n1497 VSS.n1149 5.2005
R2123 VSS.n1498 VSS.n1150 5.2005
R2124 VSS.n1499 VSS.n1498 5.2005
R2125 VSS.n1495 VSS.n1151 5.2005
R2126 VSS.n1500 VSS.n1495 5.2005
R2127 VSS.t238 VSS.n1505 5.2005
R2128 VSS.n1505 VSS.n1504 5.2005
R2129 VSS.n1496 VSS.n1152 5.2005
R2130 VSS.n1503 VSS.n1496 5.2005
R2131 VSS.n1501 VSS.n1153 5.2005
R2132 VSS.n1502 VSS.n1501 5.2005
R2133 VSS.n1489 VSS.n1388 5.2005
R2134 VSS.n1388 VSS.n1387 5.2005
R2135 VSS.n1517 VSS.n1516 5.2005
R2136 VSS.n1518 VSS.n1517 5.2005
R2137 VSS.n1637 VSS.n1299 5.2005
R2138 VSS.n1519 VSS.n1299 5.2005
R2139 VSS.n1521 VSS.n1209 5.2005
R2140 VSS.n1521 VSS.n1520 5.2005
R2141 VSS.n1524 VSS.n1523 5.2005
R2142 VSS.n1525 VSS.n1524 5.2005
R2143 VSS.n1625 VSS.n1354 5.2005
R2144 VSS.n1526 VSS.n1354 5.2005
R2145 VSS.n1528 VSS.n1527 5.2005
R2146 VSS.n1529 VSS.n1528 5.2005
R2147 VSS.n1588 VSS.n1363 5.2005
R2148 VSS.n1530 VSS.n1363 5.2005
R2149 VSS.n1586 VSS.n1364 5.2005
R2150 VSS.n1531 VSS.n1364 5.2005
R2151 VSS.n1583 VSS.n1365 5.2005
R2152 VSS.n1532 VSS.n1365 5.2005
R2153 VSS.n1535 VSS.n1534 5.2005
R2154 VSS.n1536 VSS.n1535 5.2005
R2155 VSS.n1577 VSS.n1371 5.2005
R2156 VSS.n1537 VSS.n1371 5.2005
R2157 VSS.n1575 VSS.n1372 5.2005
R2158 VSS.n1538 VSS.n1372 5.2005
R2159 VSS.n1572 VSS.n1373 5.2005
R2160 VSS.n1539 VSS.n1373 5.2005
R2161 VSS.n1375 VSS.n1374 5.2005
R2162 VSS.n1569 VSS.n1375 5.2005
R2163 VSS.n1568 VSS.n1567 5.2005
R2164 VSS.n1565 VSS.n1376 5.2005
R2165 VSS.n1564 VSS.n1377 5.2005
R2166 VSS.n1562 VSS.n1561 5.2005
R2167 VSS.n1560 VSS.n1378 5.2005
R2168 VSS.n1559 VSS.n1558 5.2005
R2169 VSS.n1557 VSS.n1379 5.2005
R2170 VSS.n1555 VSS.n1554 5.2005
R2171 VSS.n1553 VSS.n1381 5.2005
R2172 VSS.n1552 VSS.n1551 5.2005
R2173 VSS.n1550 VSS.n1382 5.2005
R2174 VSS.n1548 VSS.n1547 5.2005
R2175 VSS.n1546 VSS.n1384 5.2005
R2176 VSS.n1545 VSS.n1544 5.2005
R2177 VSS.n1543 VSS.n1385 5.2005
R2178 VSS.n1541 VSS.n1540 5.2005
R2179 VSS.n1102 VSS.n4 5.2005
R2180 VSS.n4 VSS.n2 5.2005
R2181 VSS.n1115 VSS.n1114 5.2005
R2182 VSS.n1118 VSS.n1117 5.2005
R2183 VSS.n1113 VSS.n1102 5.2005
R2184 VSS.n1119 VSS.n1113 5.2005
R2185 VSS.n1121 VSS.n1120 5.2005
R2186 VSS.n1123 VSS.n1112 5.2005
R2187 VSS.n1124 VSS.n1102 5.2005
R2188 VSS.n1124 VSS.n1111 5.2005
R2189 VSS.n1127 VSS.n1126 5.2005
R2190 VSS.n1128 VSS.n1110 5.2005
R2191 VSS.n1130 VSS.n1129 5.2005
R2192 VSS.n1132 VSS.n1108 5.2005
R2193 VSS.n1134 VSS.n1133 5.2005
R2194 VSS.n1135 VSS.n1107 5.2005
R2195 VSS.n1137 VSS.n1136 5.2005
R2196 VSS.n1139 VSS.n1106 5.2005
R2197 VSS.n1142 VSS.n1141 5.2005
R2198 VSS.n1143 VSS.n1104 5.2005
R2199 VSS.n1749 VSS.n1748 5.2005
R2200 VSS.n1748 VSS.n1747 5.2005
R2201 VSS.n1105 VSS.n1103 5.2005
R2202 VSS.n1746 VSS.n1105 5.2005
R2203 VSS.n1744 VSS.n1743 5.2005
R2204 VSS.n1745 VSS.n1744 5.2005
R2205 VSS.n1150 VSS.n1145 5.2005
R2206 VSS.n1145 VSS.n1144 5.2005
R2207 VSS.n1492 VSS.n1151 5.2005
R2208 VSS.n1493 VSS.n1492 5.2005
R2209 VSS.n1506 VSS.t238 5.2005
R2210 VSS.n1506 VSS.n1494 5.2005
R2211 VSS.n1507 VSS.n1152 5.2005
R2212 VSS.n1507 VSS.n1491 5.2005
R2213 VSS.n1508 VSS.n1153 5.2005
R2214 VSS.n1509 VSS.n1508 5.2005
R2215 VSS.n1490 VSS.n1489 5.2005
R2216 VSS.n1510 VSS.n1490 5.2005
R2217 VSS.n1516 VSS.n1515 5.2005
R2218 VSS.n1515 VSS.n1514 5.2005
R2219 VSS.n1637 VSS.n1300 5.2005
R2220 VSS.n1513 VSS.n1300 5.2005
R2221 VSS.n1511 VSS.n1209 5.2005
R2222 VSS.n1512 VSS.n1511 5.2005
R2223 VSS.n1523 VSS.n1356 5.2005
R2224 VSS.n1358 VSS.n1356 5.2005
R2225 VSS.n1625 VSS.n1593 5.2005
R2226 VSS.n1593 VSS.n1592 5.2005
R2227 VSS.n1527 VSS.n1357 5.2005
R2228 VSS.n1591 VSS.n1357 5.2005
R2229 VSS.n1589 VSS.n1588 5.2005
R2230 VSS.n1590 VSS.n1589 5.2005
R2231 VSS.n1586 VSS.n1360 5.2005
R2232 VSS.n1360 VSS.n1359 5.2005
R2233 VSS.n1583 VSS.n1582 5.2005
R2234 VSS.n1582 VSS.n1581 5.2005
R2235 VSS.n1534 VSS.n1367 5.2005
R2236 VSS.n1580 VSS.n1367 5.2005
R2237 VSS.n1578 VSS.n1577 5.2005
R2238 VSS.n1579 VSS.n1578 5.2005
R2239 VSS.n1575 VSS.n1369 5.2005
R2240 VSS.n1369 VSS.n1368 5.2005
R2241 VSS.n1572 VSS.n1571 5.2005
R2242 VSS.n1571 VSS.n1570 5.2005
R2243 VSS.n1577 VSS.n1576 5.19583
R2244 VSS.n293 VSS.n292 4.86114
R2245 VSS.n589 VSS.n588 4.52836
R2246 VSS.n587 VSS.n586 4.52836
R2247 VSS.n581 VSS.n580 4.52836
R2248 VSS.n578 VSS.n577 4.52836
R2249 VSS.n573 VSS.n572 4.52836
R2250 VSS.n570 VSS.n569 4.52836
R2251 VSS.n565 VSS.n564 4.52836
R2252 VSS.n562 VSS.n561 4.52836
R2253 VSS.n970 VSS.n90 4.52836
R2254 VSS.n100 VSS.n99 4.52836
R2255 VSS.n964 VSS.n98 4.52836
R2256 VSS.n960 VSS.n97 4.52836
R2257 VSS.n956 VSS.n96 4.52836
R2258 VSS.n952 VSS.n95 4.52836
R2259 VSS.n948 VSS.n94 4.52836
R2260 VSS.n944 VSS.n93 4.52836
R2261 VSS.n588 VSS.n552 4.52836
R2262 VSS.n586 VSS.n585 4.52836
R2263 VSS.n580 VSS.n554 4.52836
R2264 VSS.n579 VSS.n578 4.52836
R2265 VSS.n572 VSS.n556 4.52836
R2266 VSS.n571 VSS.n570 4.52836
R2267 VSS.n564 VSS.n558 4.52836
R2268 VSS.n561 VSS.n550 4.52836
R2269 VSS.n941 VSS.n93 4.52836
R2270 VSS.n945 VSS.n94 4.52836
R2271 VSS.n949 VSS.n95 4.52836
R2272 VSS.n953 VSS.n96 4.52836
R2273 VSS.n957 VSS.n97 4.52836
R2274 VSS.n961 VSS.n98 4.52836
R2275 VSS.n965 VSS.n99 4.52836
R2276 VSS.n970 VSS.n969 4.52836
R2277 VSS.n1567 VSS.n1566 4.52836
R2278 VSS.n1564 VSS.n1563 4.52836
R2279 VSS.n1380 VSS.n1378 4.52836
R2280 VSS.n1557 VSS.n1556 4.52836
R2281 VSS.n1383 VSS.n1381 4.52836
R2282 VSS.n1550 VSS.n1549 4.52836
R2283 VSS.n1386 VSS.n1384 4.52836
R2284 VSS.n1543 VSS.n1542 4.52836
R2285 VSS.n1117 VSS.n1116 4.52836
R2286 VSS.n1123 VSS.n1122 4.52836
R2287 VSS.n1126 VSS.n1125 4.52836
R2288 VSS.n1132 VSS.n1131 4.52836
R2289 VSS.n1109 VSS.n1107 4.52836
R2290 VSS.n1139 VSS.n1138 4.52836
R2291 VSS.n1141 VSS.n1140 4.52836
R2292 VSS.n1116 VSS.n1115 4.52836
R2293 VSS.n1122 VSS.n1121 4.52836
R2294 VSS.n1125 VSS.n1110 4.52836
R2295 VSS.n1131 VSS.n1130 4.52836
R2296 VSS.n1133 VSS.n1109 4.52836
R2297 VSS.n1138 VSS.n1137 4.52836
R2298 VSS.n1140 VSS.n1104 4.52836
R2299 VSS.n1542 VSS.n1541 4.52836
R2300 VSS.n1544 VSS.n1386 4.52836
R2301 VSS.n1549 VSS.n1548 4.52836
R2302 VSS.n1551 VSS.n1383 4.52836
R2303 VSS.n1556 VSS.n1555 4.52836
R2304 VSS.n1558 VSS.n1380 4.52836
R2305 VSS.n1563 VSS.n1562 4.52836
R2306 VSS.n1566 VSS.n1565 4.52836
R2307 VSS.n144 VSS.n143 4.5005
R2308 VSS.n393 VSS.n143 4.5005
R2309 VSS.n1033 VSS.n1032 4.5005
R2310 VSS.n1030 VSS.n1028 4.5005
R2311 VSS.n1025 VSS.n1024 4.5005
R2312 VSS.n1022 VSS.n1020 4.5005
R2313 VSS.n383 VSS.n382 4.5005
R2314 VSS.n380 VSS.n378 4.5005
R2315 VSS.n264 VSS.n263 4.5005
R2316 VSS.n261 VSS.n259 4.5005
R2317 VSS.n1341 VSS.n1339 4.41926
R2318 VSS.n1340 VSS.n1221 4.41926
R2319 VSS.n1631 VSS.t56 4.41926
R2320 VSS.t215 VSS.t56 4.41926
R2321 VSS.t130 VSS.t158 4.41926
R2322 VSS.n1637 VSS.t158 4.41926
R2323 VSS.n1420 VSS.n1419 4.41926
R2324 VSS.n1060 VSS.n33 4.41926
R2325 VSS.t92 VSS.n280 4.41926
R2326 VSS.n317 VSS.t199 4.41926
R2327 VSS.n971 VSS.n91 4.41926
R2328 VSS.n303 VSS.t42 4.41926
R2329 VSS.t69 VSS.n77 4.41926
R2330 VSS.n989 VSS.t264 4.41926
R2331 VSS.n295 VSS.t225 4.41926
R2332 VSS.n471 VSS.n469 4.41926
R2333 VSS.n470 VSS.n422 4.41926
R2334 VSS.n849 VSS.t25 4.41926
R2335 VSS.t218 VSS.t25 4.41926
R2336 VSS.t220 VSS.t94 4.41926
R2337 VSS.n855 VSS.t94 4.41926
R2338 VSS.n805 VSS.n804 4.41926
R2339 VSS.n1046 VSS.n46 4.34122
R2340 VSS.n51 VSS.n50 4.34122
R2341 VSS.n1040 VSS.n49 4.34122
R2342 VSS.n1036 VSS.n48 4.34122
R2343 VSS.n1017 VSS.n1016 4.34122
R2344 VSS.n1002 VSS.n59 4.34122
R2345 VSS.n1008 VSS.n61 4.34122
R2346 VSS.n1014 VSS.n63 4.34122
R2347 VSS.n347 VSS.n346 4.34122
R2348 VSS.n338 VSS.n336 4.34122
R2349 VSS.n340 VSS.n339 4.34122
R2350 VSS.n387 VSS.n386 4.34122
R2351 VSS.n364 VSS.n164 4.34122
R2352 VSS.n367 VSS.n165 4.34122
R2353 VSS.n373 VSS.n167 4.34122
R2354 VSS.n229 VSS.n228 4.34122
R2355 VSS.n232 VSS.n231 4.34122
R2356 VSS.n237 VSS.n236 4.34122
R2357 VSS.n239 VSS.n221 4.34122
R2358 VSS.n256 VSS.n160 4.34122
R2359 VSS.n252 VSS.n161 4.34122
R2360 VSS.n248 VSS.n162 4.34122
R2361 VSS.n244 VSS.n163 4.34122
R2362 VSS.n12 VSS.n10 4.34122
R2363 VSS.n1095 VSS.n9 4.34122
R2364 VSS.n1091 VSS.n8 4.34122
R2365 VSS.n1087 VSS.n7 4.34122
R2366 VSS.n208 VSS.n156 4.34122
R2367 VSS.n201 VSS.n157 4.34122
R2368 VSS.n197 VSS.n158 4.34122
R2369 VSS.n193 VSS.n159 4.34122
R2370 VSS.n1256 VSS.n1255 4.34122
R2371 VSS.n1263 VSS.n1262 4.34122
R2372 VSS.n1266 VSS.n1265 4.34122
R2373 VSS.n1271 VSS.n1270 4.34122
R2374 VSS.n1712 VSS.n1154 4.34122
R2375 VSS.n1719 VSS.n1171 4.34122
R2376 VSS.n1722 VSS.n1172 4.34122
R2377 VSS.n1730 VSS.n1174 4.34122
R2378 VSS.n124 VSS.n122 4.34122
R2379 VSS.n918 VSS.n121 4.34122
R2380 VSS.n914 VSS.n120 4.34122
R2381 VSS.n910 VSS.n119 4.34122
R2382 VSS.n785 VSS.n498 4.34122
R2383 VSS.n517 VSS.n516 4.34122
R2384 VSS.n796 VSS.n495 4.34122
R2385 VSS.n1681 VSS.n1680 4.34122
R2386 VSS.n1678 VSS.n1677 4.34122
R2387 VSS.n1242 VSS.n1240 4.34122
R2388 VSS.n1671 VSS.n1670 4.34122
R2389 VSS.n1405 VSS.n1158 4.34122
R2390 VSS.n1401 VSS.n1157 4.34122
R2391 VSS.n1397 VSS.n1156 4.34122
R2392 VSS.n1391 VSS.n1155 4.34122
R2393 VSS.n896 VSS.n105 4.34122
R2394 VSS.n893 VSS.n106 4.34122
R2395 VSS.n889 VSS.n107 4.34122
R2396 VSS.n885 VSS.n108 4.34122
R2397 VSS.n755 VSS.n502 4.34122
R2398 VSS.n761 VSS.n501 4.34122
R2399 VSS.n765 VSS.n500 4.34122
R2400 VSS.n771 VSS.n499 4.34122
R2401 VSS.n1619 VSS.n1618 4.34122
R2402 VSS.n1597 VSS.n1595 4.34122
R2403 VSS.n1610 VSS.n1609 4.34122
R2404 VSS.n1599 VSS.n1598 4.34122
R2405 VSS.n1466 VSS.n1167 4.34122
R2406 VSS.n1470 VSS.n1168 4.34122
R2407 VSS.n1474 VSS.n1169 4.34122
R2408 VSS.n1480 VSS.n1170 4.34122
R2409 VSS.n837 VSS.n117 4.34122
R2410 VSS.n834 VSS.n116 4.34122
R2411 VSS.n830 VSS.n115 4.34122
R2412 VSS.n826 VSS.n114 4.34122
R2413 VSS.n722 VSS.n511 4.34122
R2414 VSS.n728 VSS.n512 4.34122
R2415 VSS.n732 VSS.n513 4.34122
R2416 VSS.n738 VSS.n514 4.34122
R2417 VSS.n1335 VSS.n1334 4.34122
R2418 VSS.n1313 VSS.n1311 4.34122
R2419 VSS.n1326 VSS.n1325 4.34122
R2420 VSS.n1315 VSS.n1314 4.34122
R2421 VSS.n1432 VSS.n1163 4.34122
R2422 VSS.n1436 VSS.n1162 4.34122
R2423 VSS.n1440 VSS.n1161 4.34122
R2424 VSS.n1446 VSS.n1160 4.34122
R2425 VSS.n465 VSS.n110 4.34122
R2426 VSS.n462 VSS.n111 4.34122
R2427 VSS.n458 VSS.n112 4.34122
R2428 VSS.n454 VSS.n113 4.34122
R2429 VSS.n685 VSS.n507 4.34122
R2430 VSS.n691 VSS.n506 4.34122
R2431 VSS.n695 VSS.n505 4.34122
R2432 VSS.n701 VSS.n504 4.34122
R2433 VSS.n690 VSS.n507 4.34122
R2434 VSS.n694 VSS.n506 4.34122
R2435 VSS.n700 VSS.n505 4.34122
R2436 VSS.n673 VSS.n504 4.34122
R2437 VSS.n447 VSS.n113 4.34122
R2438 VSS.n455 VSS.n112 4.34122
R2439 VSS.n459 VSS.n111 4.34122
R2440 VSS.n463 VSS.n110 4.34122
R2441 VSS.n1435 VSS.n1163 4.34122
R2442 VSS.n1439 VSS.n1162 4.34122
R2443 VSS.n1445 VSS.n1161 4.34122
R2444 VSS.n1448 VSS.n1160 4.34122
R2445 VSS.n1316 VSS.n1315 4.34122
R2446 VSS.n1325 VSS.n1324 4.34122
R2447 VSS.n1327 VSS.n1313 4.34122
R2448 VSS.n1334 VSS.n1333 4.34122
R2449 VSS.n727 VSS.n511 4.34122
R2450 VSS.n731 VSS.n512 4.34122
R2451 VSS.n737 VSS.n513 4.34122
R2452 VSS.n710 VSS.n514 4.34122
R2453 VSS.n819 VSS.n114 4.34122
R2454 VSS.n827 VSS.n115 4.34122
R2455 VSS.n831 VSS.n116 4.34122
R2456 VSS.n835 VSS.n117 4.34122
R2457 VSS.n1469 VSS.n1167 4.34122
R2458 VSS.n1473 VSS.n1168 4.34122
R2459 VSS.n1479 VSS.n1169 4.34122
R2460 VSS.n1482 VSS.n1170 4.34122
R2461 VSS.n1600 VSS.n1599 4.34122
R2462 VSS.n1609 VSS.n1608 4.34122
R2463 VSS.n1611 VSS.n1597 4.34122
R2464 VSS.n1618 VSS.n1617 4.34122
R2465 VSS.n760 VSS.n502 4.34122
R2466 VSS.n764 VSS.n501 4.34122
R2467 VSS.n770 VSS.n500 4.34122
R2468 VSS.n744 VSS.n499 4.34122
R2469 VSS.n878 VSS.n108 4.34122
R2470 VSS.n886 VSS.n107 4.34122
R2471 VSS.n890 VSS.n106 4.34122
R2472 VSS.n894 VSS.n105 4.34122
R2473 VSS.n1402 VSS.n1158 4.34122
R2474 VSS.n1398 VSS.n1157 4.34122
R2475 VSS.n1392 VSS.n1156 4.34122
R2476 VSS.n1185 VSS.n1155 4.34122
R2477 VSS.n1670 VSS.n1669 4.34122
R2478 VSS.n1672 VSS.n1242 4.34122
R2479 VSS.n1677 VSS.n1676 4.34122
R2480 VSS.n1680 VSS.n1679 4.34122
R2481 VSS.n781 VSS.n498 4.34122
R2482 VSS.n788 VSS.n516 4.34122
R2483 VSS.n797 VSS.n796 4.34122
R2484 VSS.n903 VSS.n119 4.34122
R2485 VSS.n911 VSS.n120 4.34122
R2486 VSS.n915 VSS.n121 4.34122
R2487 VSS.n919 VSS.n122 4.34122
R2488 VSS.n1715 VSS.n1154 4.34122
R2489 VSS.n1716 VSS.n1171 4.34122
R2490 VSS.n1720 VSS.n1172 4.34122
R2491 VSS.n1730 VSS.n1729 4.34122
R2492 VSS.n1272 VSS.n1271 4.34122
R2493 VSS.n1265 VSS.n1252 4.34122
R2494 VSS.n1264 VSS.n1263 4.34122
R2495 VSS.n1255 VSS.n1254 4.34122
R2496 VSS.n202 VSS.n156 4.34122
R2497 VSS.n198 VSS.n157 4.34122
R2498 VSS.n194 VSS.n158 4.34122
R2499 VSS.n190 VSS.n159 4.34122
R2500 VSS.n1080 VSS.n7 4.34122
R2501 VSS.n1088 VSS.n8 4.34122
R2502 VSS.n1092 VSS.n9 4.34122
R2503 VSS.n1096 VSS.n10 4.34122
R2504 VSS.n253 VSS.n160 4.34122
R2505 VSS.n249 VSS.n161 4.34122
R2506 VSS.n245 VSS.n162 4.34122
R2507 VSS.n241 VSS.n163 4.34122
R2508 VSS.n268 VSS.n221 4.34122
R2509 VSS.n238 VSS.n237 4.34122
R2510 VSS.n231 VSS.n223 4.34122
R2511 VSS.n230 VSS.n229 4.34122
R2512 VSS.n164 VSS.n153 4.34122
R2513 VSS.n365 VSS.n165 4.34122
R2514 VSS.n373 VSS.n372 4.34122
R2515 VSS.n388 VSS.n387 4.34122
R2516 VSS.n339 VSS.n149 4.34122
R2517 VSS.n341 VSS.n338 4.34122
R2518 VSS.n346 VSS.n345 4.34122
R2519 VSS.n1016 VSS.n58 4.34122
R2520 VSS.n1005 VSS.n59 4.34122
R2521 VSS.n1006 VSS.n61 4.34122
R2522 VSS.n1014 VSS.n1013 4.34122
R2523 VSS.n182 VSS.n48 4.34122
R2524 VSS.n1037 VSS.n49 4.34122
R2525 VSS.n1041 VSS.n50 4.34122
R2526 VSS.n1046 VSS.n1045 4.34122
R2527 VSS.n294 VSS.t263 4.06576
R2528 VSS.n1653 VSS.n1652 3.72542
R2529 VSS.n1650 VSS.n1649 3.72542
R2530 VSS.n1291 VSS.n1290 3.72542
R2531 VSS.n1289 VSS.n1288 3.72542
R2532 VSS.n652 VSS.n630 3.72542
R2533 VSS.n657 VSS.n656 3.72542
R2534 VSS.n640 VSS.n639 3.72542
R2535 VSS.n637 VSS.n636 3.72542
R2536 VSS.n639 VSS.n633 3.72542
R2537 VSS.n637 VSS.n632 3.72542
R2538 VSS.n656 VSS.n655 3.72542
R2539 VSS.n658 VSS.n652 3.72542
R2540 VSS.n1290 VSS.n1284 3.72542
R2541 VSS.n1288 VSS.n1287 3.72542
R2542 VSS.n1649 VSS.n1648 3.72542
R2543 VSS.n1652 VSS.n1651 3.72542
R2544 VSS.t71 VSS.n1638 3.62389
R2545 VSS.t165 VSS.n428 3.62389
R2546 VSS.n34 VSS.n29 3.59234
R2547 VSS.n24 VSS.n22 3.59234
R2548 VSS.n292 VSS.n291 3.58947
R2549 VSS.n300 VSS.n86 3.58947
R2550 VSS.n316 VSS.n286 3.58947
R2551 VSS.n279 VSS.n174 3.58947
R2552 VSS.n1523 VSS.t280 3.53551
R2553 VSS.t280 VSS.t283 3.53551
R2554 VSS.t285 VSS.t287 3.53551
R2555 VSS.t244 VSS.t5 3.53551
R2556 VSS.t57 VSS.t196 3.53551
R2557 VSS.t45 VSS.t43 3.53551
R2558 VSS.t49 VSS.t47 3.53551
R2559 VSS.t65 VSS.t204 3.53551
R2560 VSS.t24 VSS.t67 3.53551
R2561 VSS.t201 VSS.t38 3.53551
R2562 VSS.t265 VSS.t92 3.53551
R2563 VSS.t122 VSS.t120 3.53551
R2564 VSS.t126 VSS.t122 3.53551
R2565 VSS.t257 VSS.t269 3.53551
R2566 VSS.t184 VSS.t183 3.53551
R2567 VSS.t175 VSS.t177 3.53551
R2568 VSS.t179 VSS.t181 3.53551
R2569 VSS.t117 VSS.t124 3.53551
R2570 VSS.t128 VSS.t68 3.53551
R2571 VSS.t203 VSS.t202 3.53551
R2572 VSS.t41 VSS.t84 3.53551
R2573 VSS.n664 VSS.t137 3.53551
R2574 VSS.t137 VSS.t135 3.53551
R2575 VSS.t133 VSS.t142 3.53551
R2576 VSS.n1631 VSS.n1308 3.44714
R2577 VSS.t215 VSS.n1280 3.44714
R2578 VSS.t130 VSS.n1203 3.44714
R2579 VSS.n1638 VSS.n1637 3.44714
R2580 VSS.n1516 VSS.n1190 3.44714
R2581 VSS.n1732 VSS.n1153 3.44714
R2582 VSS.n1741 VSS.n1150 3.44714
R2583 VSS.n317 VSS.n286 3.44714
R2584 VSS.n978 VSS.t91 3.44714
R2585 VSS.n303 VSS.n86 3.44714
R2586 VSS.n849 VSS.n443 3.44714
R2587 VSS.t218 VSS.n628 3.44714
R2588 VSS.t220 VSS.n402 3.44714
R2589 VSS.n855 VSS.n428 3.44714
R2590 VSS.n807 VSS.n806 3.44714
R2591 VSS.n535 VSS.n496 3.44714
R2592 VSS.n546 VSS.n544 3.44714
R2593 VSS.n1527 VSS.n1231 3.18201
R2594 VSS.n293 VSS.t41 3.18201
R2595 VSS.n134 VSS.n103 3.18201
R2596 VSS.t225 VSS.n294 3.00526
R2597 VSS.n292 VSS.t214 3.00526
R2598 VSS.n1576 VSS.t239 2.92704
R2599 VSS.n1366 VSS.t197 2.92704
R2600 VSS.n1587 VSS.t224 2.92704
R2601 VSS.t164 VSS.n24 2.74013
R2602 VSS.t23 VSS.n34 2.74013
R2603 VSS.n332 VSS.t89 2.74013
R2604 VSS.t82 VSS.n279 2.74013
R2605 VSS.n316 VSS.t40 2.74013
R2606 VSS.n291 VSS.t264 2.74013
R2607 VSS.n1527 VSS.n1236 2.65176
R2608 VSS.n1523 VSS.n1216 2.65176
R2609 VSS.n1153 VSS.t222 2.65176
R2610 VSS.t259 VSS.n1150 2.65176
R2611 VSS.n353 VSS.t58 2.65176
R2612 VSS.n353 VSS.t35 2.65176
R2613 VSS.n1053 VSS.t10 2.65176
R2614 VSS.n275 VSS.t15 2.65176
R2615 VSS.n323 VSS.t265 2.65176
R2616 VSS.n323 VSS.n185 2.65176
R2617 VSS.t269 VSS.n315 2.65176
R2618 VSS.n287 VSS.t175 2.65176
R2619 VSS.t91 VSS.t105 2.65176
R2620 VSS.n924 VSS.n103 2.65176
R2621 VSS.n664 VSS.n417 2.65176
R2622 VSS.n535 VSS.t98 2.65176
R2623 VSS.t271 VSS.n544 2.65176
R2624 VSS.n987 VSS.t128 2.56338
R2625 VSS.n301 VSS.t186 2.29826
R2626 VSS.n395 VSS.n394 2.27034
R2627 VSS.n396 VSS.n0 2.2685
R2628 VSS.n1686 VSS.t112 2.20988
R2629 VSS.n1710 VSS.t102 2.20988
R2630 VSS.n1152 VSS.t63 2.20988
R2631 VSS.t95 VSS.n1151 2.20988
R2632 VSS.n1015 VSS.t87 2.20988
R2633 VSS.n901 VSS.t234 2.20988
R2634 VSS.n777 VSS.t300 2.20988
R2635 VSS.n621 VSS.t249 2.20988
R2636 VSS.n614 VSS.t108 2.20988
R2637 VSS.n979 VSS.t181 1.85638
R2638 VSS.t100 VSS.t90 1.76801
R2639 VSS.t90 VSS.t101 1.76801
R2640 VSS.t37 VSS.t106 1.76801
R2641 VSS.t107 VSS.t37 1.76801
R2642 VSS.t0 VSS.t109 1.76801
R2643 VSS.t109 VSS.t1 1.76801
R2644 VSS.t198 VSS.t33 1.76801
R2645 VSS.t34 VSS.t198 1.76801
R2646 VSS.t103 VSS.t226 1.76801
R2647 VSS.t227 VSS.t103 1.76801
R2648 VSS.t53 VSS.t2 1.76801
R2649 VSS.t3 VSS.t53 1.76801
R2650 VSS.t283 VSS.n1522 1.76801
R2651 VSS.n1522 VSS.t285 1.76801
R2652 VSS.n1639 VSS.t71 1.76801
R2653 VSS.n1639 VSS.t76 1.76801
R2654 VSS.t6 VSS.t22 1.76801
R2655 VSS.t236 VSS.t6 1.76801
R2656 VSS.t70 VSS.t240 1.76801
R2657 VSS.t241 VSS.t70 1.76801
R2658 VSS.t222 VSS.t189 1.76801
R2659 VSS.t189 VSS.t223 1.76801
R2660 VSS.t238 VSS.t156 1.76801
R2661 VSS.t238 VSS.t157 1.76801
R2662 VSS.t258 VSS.t266 1.76801
R2663 VSS.t266 VSS.t259 1.76801
R2664 VSS.t132 VSS.t192 1.76801
R2665 VSS.t193 VSS.t132 1.76801
R2666 VSS.n1074 VSS.t88 1.76801
R2667 VSS.t43 VSS.t57 1.76801
R2668 VSS.n1066 VSS.t45 1.76801
R2669 VSS.t47 VSS.n1066 1.76801
R2670 VSS.t204 VSS.t49 1.76801
R2671 VSS.n1067 VSS.t29 1.76801
R2672 VSS.n330 VSS.n47 1.76801
R2673 VSS.n331 VSS.t235 1.76801
R2674 VSS.t153 VSS.t61 1.76801
R2675 VSS.t58 VSS.t153 1.76801
R2676 VSS.t89 VSS.t10 1.76801
R2677 VSS.n1054 VSS.t13 1.76801
R2678 VSS.n1054 VSS.t15 1.76801
R2679 VSS.t163 VSS.t17 1.76801
R2680 VSS.t200 VSS.t163 1.76801
R2681 VSS.t162 VSS.t201 1.76801
R2682 VSS.t38 VSS.t7 1.76801
R2683 VSS.t7 VSS.t36 1.76801
R2684 VSS.n359 VSS.n171 1.76801
R2685 VSS.t245 VSS.n278 1.76801
R2686 VSS.n374 VSS.t115 1.76801
R2687 VSS.n374 VSS.t120 1.76801
R2688 VSS.t267 VSS.t104 1.76801
R2689 VSS.t105 VSS.t267 1.76801
R2690 VSS.n986 VSS.n79 1.76801
R2691 VSS.t68 VSS.t209 1.76801
R2692 VSS.t209 VSS.t69 1.76801
R2693 VSS.t213 VSS.t159 1.76801
R2694 VSS.t160 VSS.t213 1.76801
R2695 VSS.n995 VSS.n69 1.76801
R2696 VSS.t110 VSS.t31 1.76801
R2697 VSS.t32 VSS.t110 1.76801
R2698 VSS.t191 VSS.t154 1.76801
R2699 VSS.t155 VSS.t191 1.76801
R2700 VSS.t66 VSS.t39 1.76801
R2701 VSS.t59 VSS.t66 1.76801
R2702 VSS.t135 VSS.n663 1.76801
R2703 VSS.n663 VSS.t133 1.76801
R2704 VSS.n645 VSS.t165 1.76801
R2705 VSS.n645 VSS.t168 1.76801
R2706 VSS.t26 VSS.t93 1.76801
R2707 VSS.t64 VSS.t26 1.76801
R2708 VSS.t301 VSS.t210 1.76801
R2709 VSS.t211 VSS.t301 1.76801
R2710 VSS.t98 VSS.t237 1.76801
R2711 VSS.t237 VSS.t99 1.76801
R2712 VSS.t228 VSS.t212 1.76801
R2713 VSS.t212 VSS.t229 1.76801
R2714 VSS.t270 VSS.t262 1.76801
R2715 VSS.t262 VSS.t271 1.76801
R2716 VSS.t242 VSS.t217 1.76801
R2717 VSS.t217 VSS.t243 1.76801
R2718 VSS.t226 VSS.n1339 1.67963
R2719 VSS.n1340 VSS.t3 1.67963
R2720 VSS.t22 VSS.n1389 1.67963
R2721 VSS.n1419 VSS.t241 1.67963
R2722 VSS.n359 VSS.n174 1.67963
R2723 VSS.n988 VSS.n77 1.67963
R2724 VSS.t154 VSS.n469 1.67963
R2725 VSS.n470 VSS.t59 1.67963
R2726 VSS.t93 VSS.n481 1.67963
R2727 VSS.n805 VSS.t211 1.67963
R2728 VSS.n1027 VSS.n1026 1.6005
R2729 VSS.n1028 VSS.n1027 1.5205
R2730 VSS.n1026 VSS.n1025 1.5205
R2731 VSS.t42 VSS.n302 1.4145
R2732 VSS.t83 VSS.n300 1.4145
R2733 VSS.t8 VSS.t83 1.32613
R2734 VSS VSS.n0 1.2565
R2735 VSS.n1489 VSS.n1488 1.23775
R2736 VSS.n1743 VSS.n1148 1.23775
R2737 VSS.n301 VSS.t185 1.23775
R2738 VSS.n672 VSS.n484 1.23775
R2739 VSS.n604 VSS.n543 1.23775
R2740 VSS.n277 VSS.n276 1.18619
R2741 VSS.n333 VSS.n332 1.18619
R2742 VSS.n1575 VSS.n1574 0.972628
R2743 VSS.n1625 VSS.n1341 0.972628
R2744 VSS.n1516 VSS.n1389 0.972628
R2745 VSS.n1487 VSS.n1420 0.972628
R2746 VSS.n1146 VSS.n1103 0.972628
R2747 VSS.n1074 VSS.n22 0.972628
R2748 VSS.n1067 VSS.n29 0.972628
R2749 VSS.n333 VSS.n331 0.972628
R2750 VSS.n276 VSS.t200 0.972628
R2751 VSS.t36 VSS.n174 0.972628
R2752 VSS.n278 VSS.n277 0.972628
R2753 VSS.n987 VSS.t117 0.972628
R2754 VSS.t202 VSS.n988 0.972628
R2755 VSS.n843 VSS.n471 0.972628
R2756 VSS.n807 VSS.n481 0.972628
R2757 VSS.n804 VSS.n803 0.972628
R2758 VSS.n597 VSS.n596 0.972628
R2759 VSS.n591 VSS.n590 0.9005
R2760 VSS.n590 VSS.n553 0.9005
R2761 VSS.n584 VSS.n553 0.9005
R2762 VSS.n584 VSS.n583 0.9005
R2763 VSS.n583 VSS.n582 0.9005
R2764 VSS.n582 VSS.n555 0.9005
R2765 VSS.n576 VSS.n555 0.9005
R2766 VSS.n576 VSS.n575 0.9005
R2767 VSS.n575 VSS.n574 0.9005
R2768 VSS.n574 VSS.n557 0.9005
R2769 VSS.n568 VSS.n557 0.9005
R2770 VSS.n568 VSS.n567 0.9005
R2771 VSS.n567 VSS.n566 0.9005
R2772 VSS.n566 VSS.n559 0.9005
R2773 VSS.n560 VSS.n559 0.9005
R2774 VSS.n560 VSS.n549 0.9005
R2775 VSS.n938 VSS.n937 0.9005
R2776 VSS.n937 VSS.n936 0.9005
R2777 VSS.n936 VSS.n934 0.9005
R2778 VSS.n934 VSS.n933 0.9005
R2779 VSS.n933 VSS.n931 0.9005
R2780 VSS.n931 VSS.n930 0.9005
R2781 VSS.n930 VSS.n101 0.9005
R2782 VSS.n625 VSS.n101 0.9005
R2783 VSS.n626 VSS.n625 0.9005
R2784 VSS.n667 VSS.n626 0.9005
R2785 VSS.n668 VSS.n667 0.9005
R2786 VSS.n669 VSS.n668 0.9005
R2787 VSS.n670 VSS.n669 0.9005
R2788 VSS.n670 VSS.n624 0.9005
R2789 VSS.n624 VSS.n623 0.9005
R2790 VSS.n623 VSS.n530 0.9005
R2791 VSS.n608 VSS.n530 0.9005
R2792 VSS.n608 VSS.n607 0.9005
R2793 VSS.n607 VSS.n606 0.9005
R2794 VSS.n606 VSS.n541 0.9005
R2795 VSS.n943 VSS.n942 0.9005
R2796 VSS.n946 VSS.n943 0.9005
R2797 VSS.n947 VSS.n946 0.9005
R2798 VSS.n950 VSS.n947 0.9005
R2799 VSS.n951 VSS.n950 0.9005
R2800 VSS.n954 VSS.n951 0.9005
R2801 VSS.n955 VSS.n954 0.9005
R2802 VSS.n958 VSS.n955 0.9005
R2803 VSS.n959 VSS.n958 0.9005
R2804 VSS.n962 VSS.n959 0.9005
R2805 VSS.n963 VSS.n962 0.9005
R2806 VSS.n966 VSS.n963 0.9005
R2807 VSS.n967 VSS.n966 0.9005
R2808 VSS.n968 VSS.n967 0.9005
R2809 VSS.n968 VSS.n89 0.9005
R2810 VSS.n973 VSS.n89 0.9005
R2811 VSS.n975 VSS.n974 0.9005
R2812 VSS.n975 VSS.n74 0.9005
R2813 VSS.n991 VSS.n74 0.9005
R2814 VSS.n992 VSS.n991 0.9005
R2815 VSS.n993 VSS.n992 0.9005
R2816 VSS.n993 VSS.n73 0.9005
R2817 VSS.n814 VSS.n73 0.9005
R2818 VSS.n815 VSS.n814 0.9005
R2819 VSS.n815 VSS.n813 0.9005
R2820 VSS.n813 VSS.n812 0.9005
R2821 VSS.n812 VSS.n810 0.9005
R2822 VSS.n810 VSS.n809 0.9005
R2823 VSS.n809 VSS.n479 0.9005
R2824 VSS.n618 VSS.n479 0.9005
R2825 VSS.n619 VSS.n618 0.9005
R2826 VSS.n619 VSS.n617 0.9005
R2827 VSS.n617 VSS.n616 0.9005
R2828 VSS.n616 VSS.n537 0.9005
R2829 VSS.n602 VSS.n537 0.9005
R2830 VSS.n602 VSS.n601 0.9005
R2831 VSS.n1570 VSS.n1368 0.9005
R2832 VSS.n1579 VSS.n1368 0.9005
R2833 VSS.n1580 VSS.n1579 0.9005
R2834 VSS.n1581 VSS.n1580 0.9005
R2835 VSS.n1581 VSS.n1359 0.9005
R2836 VSS.n1590 VSS.n1359 0.9005
R2837 VSS.n1591 VSS.n1590 0.9005
R2838 VSS.n1592 VSS.n1591 0.9005
R2839 VSS.n1592 VSS.n1358 0.9005
R2840 VSS.n1512 VSS.n1358 0.9005
R2841 VSS.n1513 VSS.n1512 0.9005
R2842 VSS.n1514 VSS.n1513 0.9005
R2843 VSS.n1514 VSS.n1510 0.9005
R2844 VSS.n1510 VSS.n1509 0.9005
R2845 VSS.n1509 VSS.n1491 0.9005
R2846 VSS.n1494 VSS.n1491 0.9005
R2847 VSS.n1494 VSS.n1493 0.9005
R2848 VSS.n1493 VSS.n1144 0.9005
R2849 VSS.n1745 VSS.n1144 0.9005
R2850 VSS.n1746 VSS.n1745 0.9005
R2851 VSS.n1114 VSS.n2 0.9005
R2852 VSS.n1118 VSS.n1114 0.9005
R2853 VSS.n1119 VSS.n1118 0.9005
R2854 VSS.n1120 VSS.n1119 0.9005
R2855 VSS.n1120 VSS.n1112 0.9005
R2856 VSS.n1112 VSS.n1111 0.9005
R2857 VSS.n1127 VSS.n1111 0.9005
R2858 VSS.n1128 VSS.n1127 0.9005
R2859 VSS.n1129 VSS.n1128 0.9005
R2860 VSS.n1129 VSS.n1108 0.9005
R2861 VSS.n1134 VSS.n1108 0.9005
R2862 VSS.n1135 VSS.n1134 0.9005
R2863 VSS.n1136 VSS.n1135 0.9005
R2864 VSS.n1136 VSS.n1106 0.9005
R2865 VSS.n1142 VSS.n1106 0.9005
R2866 VSS.n1143 VSS.n1142 0.9005
R2867 VSS.n1539 VSS.n1538 0.9005
R2868 VSS.n1538 VSS.n1537 0.9005
R2869 VSS.n1537 VSS.n1536 0.9005
R2870 VSS.n1536 VSS.n1532 0.9005
R2871 VSS.n1532 VSS.n1531 0.9005
R2872 VSS.n1531 VSS.n1530 0.9005
R2873 VSS.n1530 VSS.n1529 0.9005
R2874 VSS.n1529 VSS.n1526 0.9005
R2875 VSS.n1526 VSS.n1525 0.9005
R2876 VSS.n1525 VSS.n1520 0.9005
R2877 VSS.n1520 VSS.n1519 0.9005
R2878 VSS.n1519 VSS.n1518 0.9005
R2879 VSS.n1518 VSS.n1387 0.9005
R2880 VSS.n1502 VSS.n1387 0.9005
R2881 VSS.n1503 VSS.n1502 0.9005
R2882 VSS.n1504 VSS.n1503 0.9005
R2883 VSS.n1504 VSS.n1500 0.9005
R2884 VSS.n1500 VSS.n1499 0.9005
R2885 VSS.n1499 VSS.n1497 0.9005
R2886 VSS.n1497 VSS.n3 0.9005
R2887 VSS.n1540 VSS.n1385 0.9005
R2888 VSS.n1545 VSS.n1385 0.9005
R2889 VSS.n1546 VSS.n1545 0.9005
R2890 VSS.n1547 VSS.n1546 0.9005
R2891 VSS.n1547 VSS.n1382 0.9005
R2892 VSS.n1552 VSS.n1382 0.9005
R2893 VSS.n1553 VSS.n1552 0.9005
R2894 VSS.n1554 VSS.n1553 0.9005
R2895 VSS.n1554 VSS.n1379 0.9005
R2896 VSS.n1559 VSS.n1379 0.9005
R2897 VSS.n1560 VSS.n1559 0.9005
R2898 VSS.n1561 VSS.n1560 0.9005
R2899 VSS.n1561 VSS.n1377 0.9005
R2900 VSS.n1377 VSS.n1376 0.9005
R2901 VSS.n1568 VSS.n1376 0.9005
R2902 VSS.n1569 VSS.n1568 0.9005
R2903 VSS.n1419 VSS.n1190 0.898459
R2904 VSS.n1339 VSS.n1221 0.898459
R2905 VSS.t2 VSS.t227 0.884253
R2906 VSS.t240 VSS.t236 0.884253
R2907 VSS.t235 VSS.n330 0.884253
R2908 VSS.t13 VSS.n1053 0.884253
R2909 VSS.t17 VSS.n275 0.884253
R2910 VSS.t246 VSS.n171 0.884253
R2911 VSS.n280 VSS.t82 0.884253
R2912 VSS.t111 VSS.n977 0.884253
R2913 VSS.t186 VSS.n79 0.884253
R2914 VSS.n989 VSS.t203 0.884253
R2915 VSS.t84 VSS.n68 0.884253
R2916 VSS.t39 VSS.t155 0.884253
R2917 VSS.t210 VSS.t64 0.884253
R2918 VSS.n806 VSS.n805 0.877945
R2919 VSS.n469 VSS.n422 0.877945
R2920 VSS.n53 VSS.t176 0.8195
R2921 VSS.n53 VSS.t178 0.8195
R2922 VSS.n54 VSS.t180 0.8195
R2923 VSS.n54 VSS.t182 0.8195
R2924 VSS.n24 VSS.t60 0.795877
R2925 VSS.t30 VSS.n22 0.795877
R2926 VSS.t4 VSS.n29 0.795877
R2927 VSS.n34 VSS.t161 0.795877
R2928 VSS.t255 VSS.n333 0.795877
R2929 VSS.n332 VSS.t35 0.795877
R2930 VSS.n276 VSS.t162 0.795877
R2931 VSS.n277 VSS.t246 0.795877
R2932 VSS.n279 VSS.t81 0.795877
R2933 VSS.t62 VSS.n316 0.795877
R2934 VSS.n980 VSS.n979 0.795877
R2935 VSS.n300 VSS.t9 0.795877
R2936 VSS.n291 VSS.t263 0.795877
R2937 VSS.n998 VSS.n997 0.795877
R2938 VSS.n1338 VSS.n1337 0.7655
R2939 VSS.n1450 VSS.n1449 0.7655
R2940 VSS.n1684 VSS.n1683 0.7655
R2941 VSS.n1708 VSS.n1187 0.7655
R2942 VSS.n1688 VSS.n1225 0.7655
R2943 VSS.n1728 VSS.n1176 0.7655
R2944 VSS.n1622 VSS.n1621 0.7655
R2945 VSS.n1484 VSS.n1483 0.7655
R2946 VSS.n899 VSS.n898 0.7655
R2947 VSS.n775 VSS.n773 0.7655
R2948 VSS.n922 VSS.n125 0.7655
R2949 VSS.n799 VSS.n798 0.7655
R2950 VSS.n840 VSS.n839 0.7655
R2951 VSS.n742 VSS.n740 0.7655
R2952 VSS.n468 VSS.n467 0.7655
R2953 VSS.n708 VSS.n703 0.7655
R2954 VSS.n257 VSS.n255 0.7655
R2955 VSS.n376 VSS.n152 0.7655
R2956 VSS.n1652 VSS.n1216 0.73879
R2957 VSS.n1649 VSS.n1216 0.73879
R2958 VSS.n1290 VSS.n1195 0.73879
R2959 VSS.n1288 VSS.n1195 0.73879
R2960 VSS.n652 VSS.n417 0.73879
R2961 VSS.n656 VSS.n417 0.73879
R2962 VSS.n639 VSS.n638 0.73879
R2963 VSS.n638 VSS.n637 0.73879
R2964 VSS.n1090 VSS.n1089 0.6755
R2965 VSS.n1093 VSS.n1090 0.6755
R2966 VSS.n1094 VSS.n1093 0.6755
R2967 VSS.n1097 VSS.n1094 0.6755
R2968 VSS.n1098 VSS.n1097 0.6755
R2969 VSS.n1099 VSS.n1098 0.6755
R2970 VSS.n1071 VSS.n13 0.6755
R2971 VSS.n1072 VSS.n1071 0.6755
R2972 VSS.n1072 VSS.n1070 0.6755
R2973 VSS.n1070 VSS.n1069 0.6755
R2974 VSS.n1069 VSS.n27 0.6755
R2975 VSS.n1058 VSS.n27 0.6755
R2976 VSS.n1058 VSS.n1057 0.6755
R2977 VSS.n1057 VSS.n1056 0.6755
R2978 VSS.n1056 VSS.n38 0.6755
R2979 VSS.n188 VSS.n38 0.6755
R2980 VSS.n210 VSS.n209 0.6755
R2981 VSS.n203 VSS.n200 0.6755
R2982 VSS.n200 VSS.n199 0.6755
R2983 VSS.n199 VSS.n196 0.6755
R2984 VSS.n196 VSS.n195 0.6755
R2985 VSS.n195 VSS.n192 0.6755
R2986 VSS.n192 VSS.n191 0.6755
R2987 VSS.n1078 VSS.n1077 0.6755
R2988 VSS.n1077 VSS.n1076 0.6755
R2989 VSS.n1076 VSS.n20 0.6755
R2990 VSS.n1064 VSS.n20 0.6755
R2991 VSS.n1064 VSS.n1063 0.6755
R2992 VSS.n1063 VSS.n1062 0.6755
R2993 VSS.n1062 VSS.n31 0.6755
R2994 VSS.n212 VSS.n31 0.6755
R2995 VSS.n213 VSS.n212 0.6755
R2996 VSS.n213 VSS.n211 0.6755
R2997 VSS.n1323 VSS.n1322 0.6755
R2998 VSS.n1323 VSS.n1312 0.6755
R2999 VSS.n1328 VSS.n1312 0.6755
R3000 VSS.n1329 VSS.n1328 0.6755
R3001 VSS.n1332 VSS.n1310 0.6755
R3002 VSS.n1337 VSS.n1310 0.6755
R3003 VSS.n1627 VSS.n1338 0.6755
R3004 VSS.n1628 VSS.n1627 0.6755
R3005 VSS.n1629 VSS.n1628 0.6755
R3006 VSS.n1629 VSS.n1309 0.6755
R3007 VSS.n1451 VSS.n1309 0.6755
R3008 VSS.n1452 VSS.n1451 0.6755
R3009 VSS.n1453 VSS.n1452 0.6755
R3010 VSS.n1453 VSS.n1450 0.6755
R3011 VSS.n1433 VSS.n1431 0.6755
R3012 VSS.n1434 VSS.n1433 0.6755
R3013 VSS.n1437 VSS.n1434 0.6755
R3014 VSS.n1438 VSS.n1437 0.6755
R3015 VSS.n1441 VSS.n1438 0.6755
R3016 VSS.n1447 VSS.n1444 0.6755
R3017 VSS.n1449 VSS.n1447 0.6755
R3018 VSS.n1423 VSS.n1422 0.6755
R3019 VSS.n1424 VSS.n1423 0.6755
R3020 VSS.n1425 VSS.n1424 0.6755
R3021 VSS.n1426 VSS.n1425 0.6755
R3022 VSS.n1427 VSS.n1426 0.6755
R3023 VSS.n1428 VSS.n1427 0.6755
R3024 VSS.n1429 VSS.n1428 0.6755
R3025 VSS.n1430 VSS.n1429 0.6755
R3026 VSS.n1673 VSS.n1241 0.6755
R3027 VSS.n1674 VSS.n1673 0.6755
R3028 VSS.n1675 VSS.n1674 0.6755
R3029 VSS.n1675 VSS.n1239 0.6755
R3030 VSS.n1682 VSS.n1235 0.6755
R3031 VSS.n1683 VSS.n1682 0.6755
R3032 VSS.n1684 VSS.n1214 0.6755
R3033 VSS.n1694 VSS.n1214 0.6755
R3034 VSS.n1695 VSS.n1694 0.6755
R3035 VSS.n1696 VSS.n1695 0.6755
R3036 VSS.n1696 VSS.n1188 0.6755
R3037 VSS.n1706 VSS.n1188 0.6755
R3038 VSS.n1707 VSS.n1706 0.6755
R3039 VSS.n1708 VSS.n1707 0.6755
R3040 VSS.n1407 VSS.n1406 0.6755
R3041 VSS.n1406 VSS.n1403 0.6755
R3042 VSS.n1403 VSS.n1400 0.6755
R3043 VSS.n1400 VSS.n1399 0.6755
R3044 VSS.n1399 VSS.n1396 0.6755
R3045 VSS.n1393 VSS.n1390 0.6755
R3046 VSS.n1390 VSS.n1187 0.6755
R3047 VSS.n1409 VSS.n1247 0.6755
R3048 VSS.n1410 VSS.n1409 0.6755
R3049 VSS.n1411 VSS.n1410 0.6755
R3050 VSS.n1412 VSS.n1411 0.6755
R3051 VSS.n1413 VSS.n1412 0.6755
R3052 VSS.n1414 VSS.n1413 0.6755
R3053 VSS.n1415 VSS.n1414 0.6755
R3054 VSS.n1415 VSS.n1408 0.6755
R3055 VSS.n1269 VSS.n1268 0.6755
R3056 VSS.n1268 VSS.n1267 0.6755
R3057 VSS.n1267 VSS.n1253 0.6755
R3058 VSS.n1261 VSS.n1253 0.6755
R3059 VSS.n1258 VSS.n1257 0.6755
R3060 VSS.n1257 VSS.n1225 0.6755
R3061 VSS.n1689 VSS.n1688 0.6755
R3062 VSS.n1690 VSS.n1689 0.6755
R3063 VSS.n1690 VSS.n1201 0.6755
R3064 VSS.n1700 VSS.n1201 0.6755
R3065 VSS.n1701 VSS.n1700 0.6755
R3066 VSS.n1702 VSS.n1701 0.6755
R3067 VSS.n1702 VSS.n1200 0.6755
R3068 VSS.n1200 VSS.n1176 0.6755
R3069 VSS.n1714 VSS.n1713 0.6755
R3070 VSS.n1717 VSS.n1714 0.6755
R3071 VSS.n1718 VSS.n1717 0.6755
R3072 VSS.n1721 VSS.n1718 0.6755
R3073 VSS.n1723 VSS.n1721 0.6755
R3074 VSS.n1727 VSS.n1726 0.6755
R3075 VSS.n1728 VSS.n1727 0.6755
R3076 VSS.n1349 VSS.n1348 0.6755
R3077 VSS.n1349 VSS.n1347 0.6755
R3078 VSS.n1347 VSS.n1346 0.6755
R3079 VSS.n1346 VSS.n1345 0.6755
R3080 VSS.n1345 VSS.n1344 0.6755
R3081 VSS.n1344 VSS.n1343 0.6755
R3082 VSS.n1343 VSS.n1342 0.6755
R3083 VSS.n1342 VSS.n1178 0.6755
R3084 VSS.n1607 VSS.n1606 0.6755
R3085 VSS.n1607 VSS.n1596 0.6755
R3086 VSS.n1612 VSS.n1596 0.6755
R3087 VSS.n1613 VSS.n1612 0.6755
R3088 VSS.n1616 VSS.n1594 0.6755
R3089 VSS.n1621 VSS.n1594 0.6755
R3090 VSS.n1623 VSS.n1622 0.6755
R3091 VSS.n1623 VSS.n1303 0.6755
R3092 VSS.n1633 VSS.n1303 0.6755
R3093 VSS.n1634 VSS.n1633 0.6755
R3094 VSS.n1635 VSS.n1634 0.6755
R3095 VSS.n1635 VSS.n1302 0.6755
R3096 VSS.n1485 VSS.n1302 0.6755
R3097 VSS.n1485 VSS.n1484 0.6755
R3098 VSS.n1467 VSS.n1465 0.6755
R3099 VSS.n1468 VSS.n1467 0.6755
R3100 VSS.n1471 VSS.n1468 0.6755
R3101 VSS.n1472 VSS.n1471 0.6755
R3102 VSS.n1475 VSS.n1472 0.6755
R3103 VSS.n1481 VSS.n1478 0.6755
R3104 VSS.n1483 VSS.n1481 0.6755
R3105 VSS.n1457 VSS.n1456 0.6755
R3106 VSS.n1458 VSS.n1457 0.6755
R3107 VSS.n1459 VSS.n1458 0.6755
R3108 VSS.n1460 VSS.n1459 0.6755
R3109 VSS.n1461 VSS.n1460 0.6755
R3110 VSS.n1462 VSS.n1461 0.6755
R3111 VSS.n1463 VSS.n1462 0.6755
R3112 VSS.n1464 VSS.n1463 0.6755
R3113 VSS.n887 VSS.n884 0.6755
R3114 VSS.n888 VSS.n887 0.6755
R3115 VSS.n891 VSS.n888 0.6755
R3116 VSS.n892 VSS.n891 0.6755
R3117 VSS.n897 VSS.n895 0.6755
R3118 VSS.n898 VSS.n897 0.6755
R3119 VSS.n899 VSS.n138 0.6755
R3120 VSS.n860 VSS.n138 0.6755
R3121 VSS.n860 VSS.n859 0.6755
R3122 VSS.n859 VSS.n858 0.6755
R3123 VSS.n858 VSS.n857 0.6755
R3124 VSS.n857 VSS.n426 0.6755
R3125 VSS.n774 VSS.n426 0.6755
R3126 VSS.n775 VSS.n774 0.6755
R3127 VSS.n756 VSS.n754 0.6755
R3128 VSS.n762 VSS.n759 0.6755
R3129 VSS.n763 VSS.n762 0.6755
R3130 VSS.n766 VSS.n763 0.6755
R3131 VSS.n772 VSS.n769 0.6755
R3132 VSS.n773 VSS.n772 0.6755
R3133 VSS.n745 VSS.n141 0.6755
R3134 VSS.n746 VSS.n745 0.6755
R3135 VSS.n747 VSS.n746 0.6755
R3136 VSS.n748 VSS.n747 0.6755
R3137 VSS.n749 VSS.n748 0.6755
R3138 VSS.n751 VSS.n749 0.6755
R3139 VSS.n752 VSS.n751 0.6755
R3140 VSS.n753 VSS.n752 0.6755
R3141 VSS.n912 VSS.n909 0.6755
R3142 VSS.n913 VSS.n912 0.6755
R3143 VSS.n916 VSS.n913 0.6755
R3144 VSS.n917 VSS.n916 0.6755
R3145 VSS.n921 VSS.n920 0.6755
R3146 VSS.n922 VSS.n921 0.6755
R3147 VSS.n415 VSS.n125 0.6755
R3148 VSS.n864 VSS.n415 0.6755
R3149 VSS.n865 VSS.n864 0.6755
R3150 VSS.n866 VSS.n865 0.6755
R3151 VSS.n866 VSS.n414 0.6755
R3152 VSS.n800 VSS.n414 0.6755
R3153 VSS.n801 VSS.n800 0.6755
R3154 VSS.n801 VSS.n799 0.6755
R3155 VSS.n782 VSS.n780 0.6755
R3156 VSS.n787 VSS.n786 0.6755
R3157 VSS.n789 VSS.n787 0.6755
R3158 VSS.n790 VSS.n789 0.6755
R3159 VSS.n793 VSS.n494 0.6755
R3160 VSS.n798 VSS.n494 0.6755
R3161 VSS.n518 VSS.n130 0.6755
R3162 VSS.n519 VSS.n518 0.6755
R3163 VSS.n520 VSS.n519 0.6755
R3164 VSS.n521 VSS.n520 0.6755
R3165 VSS.n522 VSS.n521 0.6755
R3166 VSS.n524 VSS.n522 0.6755
R3167 VSS.n525 VSS.n524 0.6755
R3168 VSS.n779 VSS.n525 0.6755
R3169 VSS.n828 VSS.n825 0.6755
R3170 VSS.n829 VSS.n828 0.6755
R3171 VSS.n832 VSS.n829 0.6755
R3172 VSS.n833 VSS.n832 0.6755
R3173 VSS.n838 VSS.n836 0.6755
R3174 VSS.n839 VSS.n838 0.6755
R3175 VSS.n841 VSS.n840 0.6755
R3176 VSS.n841 VSS.n438 0.6755
R3177 VSS.n851 VSS.n438 0.6755
R3178 VSS.n852 VSS.n851 0.6755
R3179 VSS.n853 VSS.n852 0.6755
R3180 VSS.n853 VSS.n437 0.6755
R3181 VSS.n741 VSS.n437 0.6755
R3182 VSS.n742 VSS.n741 0.6755
R3183 VSS.n723 VSS.n721 0.6755
R3184 VSS.n729 VSS.n726 0.6755
R3185 VSS.n730 VSS.n729 0.6755
R3186 VSS.n733 VSS.n730 0.6755
R3187 VSS.n739 VSS.n736 0.6755
R3188 VSS.n740 VSS.n739 0.6755
R3189 VSS.n712 VSS.n711 0.6755
R3190 VSS.n713 VSS.n712 0.6755
R3191 VSS.n714 VSS.n713 0.6755
R3192 VSS.n715 VSS.n714 0.6755
R3193 VSS.n716 VSS.n715 0.6755
R3194 VSS.n718 VSS.n716 0.6755
R3195 VSS.n719 VSS.n718 0.6755
R3196 VSS.n720 VSS.n719 0.6755
R3197 VSS.n456 VSS.n453 0.6755
R3198 VSS.n457 VSS.n456 0.6755
R3199 VSS.n460 VSS.n457 0.6755
R3200 VSS.n461 VSS.n460 0.6755
R3201 VSS.n466 VSS.n464 0.6755
R3202 VSS.n467 VSS.n466 0.6755
R3203 VSS.n845 VSS.n468 0.6755
R3204 VSS.n846 VSS.n845 0.6755
R3205 VSS.n847 VSS.n846 0.6755
R3206 VSS.n847 VSS.n444 0.6755
R3207 VSS.n704 VSS.n444 0.6755
R3208 VSS.n706 VSS.n704 0.6755
R3209 VSS.n707 VSS.n706 0.6755
R3210 VSS.n708 VSS.n707 0.6755
R3211 VSS.n686 VSS.n684 0.6755
R3212 VSS.n692 VSS.n689 0.6755
R3213 VSS.n693 VSS.n692 0.6755
R3214 VSS.n696 VSS.n693 0.6755
R3215 VSS.n702 VSS.n699 0.6755
R3216 VSS.n703 VSS.n702 0.6755
R3217 VSS.n675 VSS.n674 0.6755
R3218 VSS.n676 VSS.n675 0.6755
R3219 VSS.n677 VSS.n676 0.6755
R3220 VSS.n678 VSS.n677 0.6755
R3221 VSS.n679 VSS.n678 0.6755
R3222 VSS.n681 VSS.n679 0.6755
R3223 VSS.n682 VSS.n681 0.6755
R3224 VSS.n683 VSS.n682 0.6755
R3225 VSS.n254 VSS.n251 0.6755
R3226 VSS.n251 VSS.n250 0.6755
R3227 VSS.n250 VSS.n247 0.6755
R3228 VSS.n247 VSS.n246 0.6755
R3229 VSS.n246 VSS.n243 0.6755
R3230 VSS.n243 VSS.n242 0.6755
R3231 VSS.n240 VSS.n222 0.6755
R3232 VSS.n235 VSS.n222 0.6755
R3233 VSS.n235 VSS.n234 0.6755
R3234 VSS.n234 VSS.n233 0.6755
R3235 VSS.n233 VSS.n224 0.6755
R3236 VSS.n227 VSS.n224 0.6755
R3237 VSS.n1038 VSS.n1035 0.6755
R3238 VSS.n1039 VSS.n1038 0.6755
R3239 VSS.n1042 VSS.n1039 0.6755
R3240 VSS.n1043 VSS.n1042 0.6755
R3241 VSS.n1044 VSS.n1043 0.6755
R3242 VSS.n1044 VSS.n45 0.6755
R3243 VSS.n1049 VSS.n45 0.6755
R3244 VSS.n1051 VSS.n1050 0.6755
R3245 VSS.n1051 VSS.n44 0.6755
R3246 VSS.n321 VSS.n44 0.6755
R3247 VSS.n321 VSS.n320 0.6755
R3248 VSS.n320 VSS.n319 0.6755
R3249 VSS.n319 VSS.n282 0.6755
R3250 VSS.n283 VSS.n282 0.6755
R3251 VSS.n283 VSS.n83 0.6755
R3252 VSS.n982 VSS.n83 0.6755
R3253 VSS.n983 VSS.n982 0.6755
R3254 VSS.n984 VSS.n983 0.6755
R3255 VSS.n984 VSS.n82 0.6755
R3256 VSS.n82 VSS.n65 0.6755
R3257 VSS.n1000 VSS.n65 0.6755
R3258 VSS.n1001 VSS.n1000 0.6755
R3259 VSS.n1003 VSS.n55 0.6755
R3260 VSS.n1004 VSS.n1003 0.6755
R3261 VSS.n1007 VSS.n1004 0.6755
R3262 VSS.n1009 VSS.n1007 0.6755
R3263 VSS.n1010 VSS.n1009 0.6755
R3264 VSS.n1011 VSS.n1010 0.6755
R3265 VSS.n1012 VSS.n1011 0.6755
R3266 VSS.n328 VSS.n327 0.6755
R3267 VSS.n327 VSS.n326 0.6755
R3268 VSS.n326 VSS.n183 0.6755
R3269 VSS.n312 VSS.n183 0.6755
R3270 VSS.n313 VSS.n312 0.6755
R3271 VSS.n313 VSS.n311 0.6755
R3272 VSS.n311 VSS.n310 0.6755
R3273 VSS.n310 VSS.n307 0.6755
R3274 VSS.n307 VSS.n306 0.6755
R3275 VSS.n306 VSS.n305 0.6755
R3276 VSS.n305 VSS.n299 0.6755
R3277 VSS.n299 VSS.n298 0.6755
R3278 VSS.n298 VSS.n290 0.6755
R3279 VSS.n290 VSS.n289 0.6755
R3280 VSS.n289 VSS.n56 0.6755
R3281 VSS.n385 VSS.n150 0.6755
R3282 VSS.n337 VSS.n150 0.6755
R3283 VSS.n342 VSS.n337 0.6755
R3284 VSS.n343 VSS.n342 0.6755
R3285 VSS.n344 VSS.n343 0.6755
R3286 VSS.n344 VSS.n335 0.6755
R3287 VSS.n363 VSS.n151 0.6755
R3288 VSS.n366 VSS.n363 0.6755
R3289 VSS.n368 VSS.n366 0.6755
R3290 VSS.n369 VSS.n368 0.6755
R3291 VSS.n370 VSS.n369 0.6755
R3292 VSS.n371 VSS.n370 0.6755
R3293 VSS.n942 VSS.n938 0.653
R3294 VSS.n974 VSS.n973 0.653
R3295 VSS.n600 VSS.n549 0.653
R3296 VSS.n1747 VSS.n1143 0.653
R3297 VSS.n1540 VSS.n1539 0.653
R3298 VSS.n1570 VSS.n1569 0.653
R3299 VSS.n1099 VSS.n13 0.653
R3300 VSS.n1018 VSS.n56 0.653
R3301 VSS.n1086 VSS.n17 0.61925
R3302 VSS.n759 VSS.n758 0.563
R3303 VSS.n786 VSS.n784 0.563
R3304 VSS.n726 VSS.n725 0.563
R3305 VSS.n689 VSS.n688 0.563
R3306 VSS.n1035 VSS.n1034 0.563
R3307 VSS.n1019 VSS.n55 0.563
R3308 VSS.n191 VSS.n188 0.5405
R3309 VSS.n211 VSS.n210 0.5405
R3310 VSS.n1647 VSS.n1278 0.5405
R3311 VSS.n1655 VSS.n1654 0.5405
R3312 VSS.n1294 VSS.n1293 0.5405
R3313 VSS.n1286 VSS.n1282 0.5405
R3314 VSS.n1431 VSS.n1430 0.5405
R3315 VSS.n1408 VSS.n1407 0.5405
R3316 VSS.n1713 VSS.n1178 0.5405
R3317 VSS.n1465 VSS.n1464 0.5405
R3318 VSS.n634 VSS.n631 0.5405
R3319 VSS.n643 VSS.n642 0.5405
R3320 VSS.n654 VSS.n653 0.5405
R3321 VSS.n661 VSS.n660 0.5405
R3322 VSS.n754 VSS.n753 0.5405
R3323 VSS.n780 VSS.n779 0.5405
R3324 VSS.n721 VSS.n720 0.5405
R3325 VSS.n684 VSS.n683 0.5405
R3326 VSS.n242 VSS.n177 0.5405
R3327 VSS.n1050 VSS.n1049 0.5405
R3328 VSS.n1012 VSS.n1001 0.5405
R3329 VSS.n371 VSS.n362 0.5405
R3330 VSS.n1086 VSS.n1085 0.50675
R3331 VSS.n1322 VSS.n1321 0.50675
R3332 VSS.n1246 VSS.n1241 0.50675
R3333 VSS.n1269 VSS.n1251 0.50675
R3334 VSS.n1606 VSS.n1605 0.50675
R3335 VSS.n593 VSS.n592 0.48425
R3336 VSS.n1752 VSS.n1751 0.48425
R3337 VSS.n593 VSS.n541 0.4505
R3338 VSS.n601 VSS.n600 0.4505
R3339 VSS.n1747 VSS.n1746 0.4505
R3340 VSS.n1751 VSS.n3 0.4505
R3341 VSS.n1659 VSS.n1278 0.4505
R3342 VSS.n1660 VSS.n1659 0.4505
R3343 VSS.n1660 VSS.n1277 0.4505
R3344 VSS.n1294 VSS.n1277 0.4505
R3345 VSS.n1656 VSS.n1655 0.4505
R3346 VSS.n1656 VSS.n1644 0.4505
R3347 VSS.n1644 VSS.n1643 0.4505
R3348 VSS.n1643 VSS.n1282 0.4505
R3349 VSS.n661 VSS.n650 0.4505
R3350 VSS.n650 VSS.n649 0.4505
R3351 VSS.n649 VSS.n648 0.4505
R3352 VSS.n648 VSS.n631 0.4505
R3353 VSS.n653 VSS.n399 0.4505
R3354 VSS.n870 VSS.n399 0.4505
R3355 VSS.n870 VSS.n398 0.4505
R3356 VSS.n643 VSS.n398 0.4505
R3357 VSS.n883 VSS.n879 0.4505
R3358 VSS.n908 VSS.n904 0.4505
R3359 VSS.n824 VSS.n820 0.4505
R3360 VSS.n452 VSS.n448 0.4505
R3361 VSS.n226 VSS.n178 0.4505
R3362 VSS.n355 VSS.n178 0.4505
R3363 VSS.n356 VSS.n355 0.4505
R3364 VSS.n357 VSS.n356 0.4505
R3365 VSS.n357 VSS.n177 0.4505
R3366 VSS.n271 VSS.n220 0.4505
R3367 VSS.n272 VSS.n271 0.4505
R3368 VSS.n273 VSS.n272 0.4505
R3369 VSS.n273 VSS.n219 0.4505
R3370 VSS.n255 VSS.n219 0.4505
R3371 VSS.n350 VSS.n349 0.4505
R3372 VSS.n351 VSS.n350 0.4505
R3373 VSS.n351 VSS.n169 0.4505
R3374 VSS.n361 VSS.n169 0.4505
R3375 VSS.n362 VSS.n361 0.4505
R3376 VSS.n390 VSS.n147 0.4505
R3377 VSS.n216 VSS.n147 0.4505
R3378 VSS.n217 VSS.n216 0.4505
R3379 VSS.n217 VSS.n215 0.4505
R3380 VSS.n215 VSS.n152 0.4505
R3381 VSS.n295 VSS.t214 0.442376
R3382 VSS.n1662 VSS.n1661 0.4405
R3383 VSS.n872 VSS.n871 0.4405
R3384 VSS.n1047 VSS.n1046 0.430889
R3385 VSS.n1047 VSS.n50 0.430889
R3386 VSS.n1047 VSS.n49 0.430889
R3387 VSS.n1047 VSS.n48 0.430889
R3388 VSS.n1016 VSS.n1015 0.430889
R3389 VSS.n1015 VSS.n59 0.430889
R3390 VSS.n1015 VSS.n61 0.430889
R3391 VSS.n1015 VSS.n1014 0.430889
R3392 VSS.n346 VSS.n36 0.430889
R3393 VSS.n338 VSS.n36 0.430889
R3394 VSS.n339 VSS.n36 0.430889
R3395 VSS.n387 VSS.n36 0.430889
R3396 VSS.n374 VSS.n164 0.430889
R3397 VSS.n374 VSS.n165 0.430889
R3398 VSS.n374 VSS.n373 0.430889
R3399 VSS.n229 VSS.n36 0.430889
R3400 VSS.n231 VSS.n36 0.430889
R3401 VSS.n237 VSS.n36 0.430889
R3402 VSS.n221 VSS.n36 0.430889
R3403 VSS.n374 VSS.n160 0.430889
R3404 VSS.n374 VSS.n161 0.430889
R3405 VSS.n374 VSS.n162 0.430889
R3406 VSS.n374 VSS.n163 0.430889
R3407 VSS.n1101 VSS.n10 0.430889
R3408 VSS.n1101 VSS.n9 0.430889
R3409 VSS.n1101 VSS.n8 0.430889
R3410 VSS.n1101 VSS.n7 0.430889
R3411 VSS.n374 VSS.n156 0.430889
R3412 VSS.n374 VSS.n157 0.430889
R3413 VSS.n374 VSS.n158 0.430889
R3414 VSS.n374 VSS.n159 0.430889
R3415 VSS.n1255 VSS.n1236 0.430889
R3416 VSS.n1263 VSS.n1236 0.430889
R3417 VSS.n1265 VSS.n1236 0.430889
R3418 VSS.n1271 VSS.n1236 0.430889
R3419 VSS.n1731 VSS.n1154 0.430889
R3420 VSS.n1731 VSS.n1171 0.430889
R3421 VSS.n1731 VSS.n1172 0.430889
R3422 VSS.n1731 VSS.n1730 0.430889
R3423 VSS.n924 VSS.n122 0.430889
R3424 VSS.n924 VSS.n121 0.430889
R3425 VSS.n924 VSS.n120 0.430889
R3426 VSS.n924 VSS.n119 0.430889
R3427 VSS.n795 VSS.n498 0.430889
R3428 VSS.n795 VSS.n516 0.430889
R3429 VSS.n796 VSS.n795 0.430889
R3430 VSS.n1680 VSS.n1236 0.430889
R3431 VSS.n1677 VSS.n1236 0.430889
R3432 VSS.n1242 VSS.n1236 0.430889
R3433 VSS.n1670 VSS.n1236 0.430889
R3434 VSS.n1731 VSS.n1158 0.430889
R3435 VSS.n1731 VSS.n1157 0.430889
R3436 VSS.n1731 VSS.n1156 0.430889
R3437 VSS.n1731 VSS.n1155 0.430889
R3438 VSS.n924 VSS.n105 0.430889
R3439 VSS.n924 VSS.n106 0.430889
R3440 VSS.n924 VSS.n107 0.430889
R3441 VSS.n924 VSS.n108 0.430889
R3442 VSS.n795 VSS.n502 0.430889
R3443 VSS.n795 VSS.n501 0.430889
R3444 VSS.n795 VSS.n500 0.430889
R3445 VSS.n795 VSS.n499 0.430889
R3446 VSS.n1618 VSS.n1236 0.430889
R3447 VSS.n1597 VSS.n1236 0.430889
R3448 VSS.n1609 VSS.n1236 0.430889
R3449 VSS.n1599 VSS.n1236 0.430889
R3450 VSS.n1731 VSS.n1167 0.430889
R3451 VSS.n1731 VSS.n1168 0.430889
R3452 VSS.n1731 VSS.n1169 0.430889
R3453 VSS.n1731 VSS.n1170 0.430889
R3454 VSS.n924 VSS.n117 0.430889
R3455 VSS.n924 VSS.n116 0.430889
R3456 VSS.n924 VSS.n115 0.430889
R3457 VSS.n924 VSS.n114 0.430889
R3458 VSS.n795 VSS.n511 0.430889
R3459 VSS.n795 VSS.n512 0.430889
R3460 VSS.n795 VSS.n513 0.430889
R3461 VSS.n795 VSS.n514 0.430889
R3462 VSS.n1334 VSS.n1236 0.430889
R3463 VSS.n1313 VSS.n1236 0.430889
R3464 VSS.n1325 VSS.n1236 0.430889
R3465 VSS.n1315 VSS.n1236 0.430889
R3466 VSS.n1731 VSS.n1163 0.430889
R3467 VSS.n1731 VSS.n1162 0.430889
R3468 VSS.n1731 VSS.n1161 0.430889
R3469 VSS.n1731 VSS.n1160 0.430889
R3470 VSS.n924 VSS.n110 0.430889
R3471 VSS.n924 VSS.n111 0.430889
R3472 VSS.n924 VSS.n112 0.430889
R3473 VSS.n924 VSS.n113 0.430889
R3474 VSS.n795 VSS.n507 0.430889
R3475 VSS.n795 VSS.n506 0.430889
R3476 VSS.n795 VSS.n505 0.430889
R3477 VSS.n795 VSS.n504 0.430889
R3478 VSS.n757 VSS.t172 0.41
R3479 VSS.n757 VSS.t169 0.41
R3480 VSS.n783 VSS.t171 0.41
R3481 VSS.n783 VSS.t170 0.41
R3482 VSS.n724 VSS.t166 0.41
R3483 VSS.n724 VSS.t173 0.41
R3484 VSS.n687 VSS.t167 0.41
R3485 VSS.n687 VSS.t174 0.41
R3486 VSS.n1332 VSS.n1331 0.383
R3487 VSS.n1444 VSS.n1443 0.383
R3488 VSS.n1237 VSS.n1235 0.383
R3489 VSS.n1394 VSS.n1393 0.383
R3490 VSS.n1259 VSS.n1258 0.383
R3491 VSS.n1726 VSS.n1725 0.383
R3492 VSS.n1616 VSS.n1615 0.383
R3493 VSS.n1478 VSS.n1477 0.383
R3494 VSS.n1078 VSS.n18 0.37175
R3495 VSS.n1422 VSS.n1276 0.37175
R3496 VSS.n1667 VSS.n1247 0.37175
R3497 VSS.n1348 VSS.n1274 0.37175
R3498 VSS.n1456 VSS.n1275 0.37175
R3499 VSS.n877 VSS.n141 0.37175
R3500 VSS.n130 VSS.n128 0.37175
R3501 VSS.n711 VSS.n142 0.37175
R3502 VSS.n674 VSS.n397 0.37175
R3503 VSS.n266 VSS.n220 0.37175
R3504 VSS.n328 VSS.n145 0.37175
R3505 VSS.n391 VSS.n390 0.37175
R3506 VSS.n258 VSS.n257 0.366125
R3507 VSS.n267 VSS.n265 0.366125
R3508 VSS.n384 VSS.n146 0.366125
R3509 VSS.n377 VSS.n376 0.366125
R3510 VSS.n209 VSS.n207 0.338
R3511 VSS.n207 VSS.n203 0.338
R3512 VSS.n1647 VSS.n1646 0.338
R3513 VSS.n1646 VSS.n1645 0.338
R3514 VSS.n1654 VSS.n1645 0.338
R3515 VSS.n1293 VSS.n1292 0.338
R3516 VSS.n1292 VSS.n1285 0.338
R3517 VSS.n1286 VSS.n1285 0.338
R3518 VSS.n642 VSS.n641 0.338
R3519 VSS.n641 VSS.n635 0.338
R3520 VSS.n635 VSS.n634 0.338
R3521 VSS.n654 VSS.n651 0.338
R3522 VSS.n659 VSS.n651 0.338
R3523 VSS.n660 VSS.n659 0.338
R3524 VSS.n895 VSS.n139 0.338
R3525 VSS.n769 VSS.n768 0.338
R3526 VSS.n920 VSS.n126 0.338
R3527 VSS.n793 VSS.n792 0.338
R3528 VSS.n836 VSS.n817 0.338
R3529 VSS.n736 VSS.n735 0.338
R3530 VSS.n464 VSS.n445 0.338
R3531 VSS.n699 VSS.n698 0.338
R3532 VSS.n588 VSS.n551 0.337318
R3533 VSS.n586 VSS.n551 0.337318
R3534 VSS.n580 VSS.n551 0.337318
R3535 VSS.n578 VSS.n551 0.337318
R3536 VSS.n572 VSS.n551 0.337318
R3537 VSS.n570 VSS.n551 0.337318
R3538 VSS.n564 VSS.n551 0.337318
R3539 VSS.n561 VSS.n551 0.337318
R3540 VSS.n971 VSS.n970 0.337318
R3541 VSS.n971 VSS.n99 0.337318
R3542 VSS.n971 VSS.n98 0.337318
R3543 VSS.n971 VSS.n97 0.337318
R3544 VSS.n971 VSS.n96 0.337318
R3545 VSS.n971 VSS.n95 0.337318
R3546 VSS.n971 VSS.n94 0.337318
R3547 VSS.n971 VSS.n93 0.337318
R3548 VSS.n1566 VSS.n1374 0.337318
R3549 VSS.n1563 VSS.n1374 0.337318
R3550 VSS.n1380 VSS.n1374 0.337318
R3551 VSS.n1556 VSS.n1374 0.337318
R3552 VSS.n1383 VSS.n1374 0.337318
R3553 VSS.n1549 VSS.n1374 0.337318
R3554 VSS.n1386 VSS.n1374 0.337318
R3555 VSS.n1542 VSS.n1374 0.337318
R3556 VSS.n1116 VSS.n1102 0.337318
R3557 VSS.n1122 VSS.n1102 0.337318
R3558 VSS.n1125 VSS.n1102 0.337318
R3559 VSS.n1131 VSS.n1102 0.337318
R3560 VSS.n1109 VSS.n1102 0.337318
R3561 VSS.n1138 VSS.n1102 0.337318
R3562 VSS.n1140 VSS.n1102 0.337318
R3563 VSS.n393 VSS.n392 0.335833
R3564 VSS.n1083 VSS.t48 0.3281
R3565 VSS.n1083 VSS.t50 0.3281
R3566 VSS.n1082 VSS.t44 0.3281
R3567 VSS.n1082 VSS.t46 0.3281
R3568 VSS.n15 VSS.t207 0.3281
R3569 VSS.n15 VSS.t208 0.3281
R3570 VSS.n14 VSS.t205 0.3281
R3571 VSS.n14 VSS.t206 0.3281
R3572 VSS.n227 VSS.n226 0.3155
R3573 VSS.n349 VSS.n335 0.3155
R3574 VSS.n258 VSS.n254 0.309875
R3575 VSS.n265 VSS.n240 0.309875
R3576 VSS.n385 VSS.n384 0.309875
R3577 VSS.n377 VSS.n151 0.309875
R3578 VSS.n1081 VSS.n18 0.28175
R3579 VSS.n145 VSS.n52 0.28175
R3580 VSS.n1421 VSS.t73 0.2735
R3581 VSS.n1421 VSS.t80 0.2735
R3582 VSS.n1404 VSS.t74 0.2735
R3583 VSS.n1404 VSS.t78 0.2735
R3584 VSS.n1177 VSS.t72 0.2735
R3585 VSS.n1177 VSS.t77 0.2735
R3586 VSS.n1455 VSS.t75 0.2735
R3587 VSS.n1455 VSS.t79 0.2735
R3588 VSS.n884 VSS.n883 0.2255
R3589 VSS.n140 VSS.n139 0.2255
R3590 VSS.n768 VSS.n767 0.2255
R3591 VSS.n909 VSS.n908 0.2255
R3592 VSS.n127 VSS.n126 0.2255
R3593 VSS.n792 VSS.n791 0.2255
R3594 VSS.n825 VSS.n824 0.2255
R3595 VSS.n818 VSS.n817 0.2255
R3596 VSS.n735 VSS.n734 0.2255
R3597 VSS.n453 VSS.n452 0.2255
R3598 VSS.n446 VSS.n445 0.2255
R3599 VSS.n698 VSS.n697 0.2255
R3600 VSS.n1024 VSS.n1022 0.189974
R3601 VSS.n1032 VSS.n1030 0.189974
R3602 VSS.n382 VSS.n380 0.189974
R3603 VSS.n263 VSS.n261 0.189974
R3604 VSS.n592 VSS.n591 0.16925
R3605 VSS.n1752 VSS.n2 0.16925
R3606 VSS.n1085 VSS.n1081 0.16925
R3607 VSS.n1317 VSS.n1276 0.16925
R3608 VSS.n1321 VSS.n1317 0.16925
R3609 VSS.n1668 VSS.n1667 0.16925
R3610 VSS.n1668 VSS.n1246 0.16925
R3611 VSS.n1274 VSS.n1273 0.16925
R3612 VSS.n1273 VSS.n1251 0.16925
R3613 VSS.n1601 VSS.n1275 0.16925
R3614 VSS.n1605 VSS.n1601 0.16925
R3615 VSS.n879 VSS.n877 0.16925
R3616 VSS.n904 VSS.n128 0.16925
R3617 VSS.n820 VSS.n142 0.16925
R3618 VSS.n448 VSS.n397 0.16925
R3619 VSS.n267 VSS.n266 0.16925
R3620 VSS.n391 VSS.n146 0.16925
R3621 VSS.n205 VSS.t232 0.1643
R3622 VSS.n205 VSS.t233 0.1643
R3623 VSS.n204 VSS.t230 0.1643
R3624 VSS.n204 VSS.t231 0.1643
R3625 VSS.n881 VSS.t141 0.1643
R3626 VSS.n881 VSS.t143 0.1643
R3627 VSS.n880 VSS.t144 0.1643
R3628 VSS.n880 VSS.t147 0.1643
R3629 VSS.n906 VSS.t145 0.1643
R3630 VSS.n906 VSS.t146 0.1643
R3631 VSS.n905 VSS.t139 0.1643
R3632 VSS.n905 VSS.t140 0.1643
R3633 VSS.n822 VSS.t151 0.1643
R3634 VSS.n822 VSS.t148 0.1643
R3635 VSS.n821 VSS.t138 0.1643
R3636 VSS.n821 VSS.t149 0.1643
R3637 VSS.n450 VSS.t134 0.1643
R3638 VSS.n450 VSS.t152 0.1643
R3639 VSS.n449 VSS.t150 0.1643
R3640 VSS.n449 VSS.t136 0.1643
R3641 VSS.n1021 VSS.t129 0.1643
R3642 VSS.n1021 VSS.t119 0.1643
R3643 VSS.n1023 VSS.t125 0.1643
R3644 VSS.n1023 VSS.t118 0.1643
R3645 VSS.n1029 VSS.t123 0.1643
R3646 VSS.n1029 VSS.t127 0.1643
R3647 VSS.n1031 VSS.t116 0.1643
R3648 VSS.n1031 VSS.t121 0.1643
R3649 VSS.n1033 VSS.n1028 0.1605
R3650 VSS.n1025 VSS.n1020 0.1605
R3651 VSS.n383 VSS.n378 0.1605
R3652 VSS.n264 VSS.n259 0.1605
R3653 VSS.n1330 VSS.n1329 0.158
R3654 VSS.n1442 VSS.n1441 0.158
R3655 VSS.n1239 VSS.n1238 0.158
R3656 VSS.n1396 VSS.n1395 0.158
R3657 VSS.n1261 VSS.n1260 0.158
R3658 VSS.n1724 VSS.n1723 0.158
R3659 VSS.n1614 VSS.n1613 0.158
R3660 VSS.n1476 VSS.n1475 0.158
R3661 VSS.n379 VSS.t16 0.137
R3662 VSS.n379 VSS.t18 0.137
R3663 VSS.n381 VSS.t12 0.137
R3664 VSS.n381 VSS.t14 0.137
R3665 VSS.n260 VSS.t20 0.137
R3666 VSS.n260 VSS.t21 0.137
R3667 VSS.n262 VSS.t11 0.137
R3668 VSS.n262 VSS.t19 0.137
R3669 VSS.n1331 VSS.n1330 0.1355
R3670 VSS.n1443 VSS.n1442 0.1355
R3671 VSS.n1238 VSS.n1237 0.1355
R3672 VSS.n1395 VSS.n1394 0.1355
R3673 VSS.n1260 VSS.n1259 0.1355
R3674 VSS.n1725 VSS.n1724 0.1355
R3675 VSS.n1615 VSS.n1614 0.1355
R3676 VSS.n1477 VSS.n1476 0.1355
R3677 VSS.n892 VSS.n140 0.113
R3678 VSS.n758 VSS.n756 0.113
R3679 VSS.n767 VSS.n766 0.113
R3680 VSS.n917 VSS.n127 0.113
R3681 VSS.n784 VSS.n782 0.113
R3682 VSS.n791 VSS.n790 0.113
R3683 VSS.n833 VSS.n818 0.113
R3684 VSS.n725 VSS.n723 0.113
R3685 VSS.n734 VSS.n733 0.113
R3686 VSS.n461 VSS.n446 0.113
R3687 VSS.n688 VSS.n686 0.113
R3688 VSS.n697 VSS.n696 0.113
R3689 VSS.n1034 VSS.n52 0.113
R3690 VSS.n1019 VSS.n1018 0.113
R3691 VSS.n1319 VSS.t298 0.1097
R3692 VSS.n1319 VSS.t299 0.1097
R3693 VSS.n1318 VSS.t295 0.1097
R3694 VSS.n1318 VSS.t297 0.1097
R3695 VSS.n1244 VSS.t289 0.1097
R3696 VSS.n1244 VSS.t290 0.1097
R3697 VSS.n1243 VSS.t291 0.1097
R3698 VSS.n1243 VSS.t292 0.1097
R3699 VSS.n1249 VSS.t286 0.1097
R3700 VSS.n1249 VSS.t288 0.1097
R3701 VSS.n1248 VSS.t282 0.1097
R3702 VSS.n1248 VSS.t284 0.1097
R3703 VSS.n1603 VSS.t294 0.1097
R3704 VSS.n1603 VSS.t296 0.1097
R3705 VSS.n1602 VSS.t281 0.1097
R3706 VSS.n1602 VSS.t293 0.1097
R3707 VSS.t287 VSS.n1308 0.0888753
R3708 VSS.n978 VSS.t111 0.0888753
R3709 VSS.t142 VSS.n443 0.0888753
R3710 VSS.n1665 VSS.n1664 0.0597105
R3711 VSS.n875 VSS.n874 0.0597105
R3712 VSS.n1089 VSS.n17 0.05675
R3713 VSS.n395 VSS.n143 0.0225753
R3714 VSS.n394 VSS.n393 0.00566183
R3715 VSS.n394 VSS.n144 0.00566183
R3716 a_43000_n37702.n1 a_43000_n37702.t0 19.0047
R3717 a_43000_n37702.n2 a_43000_n37702.n1 8.64669
R3718 a_43000_n37702.n1 a_43000_n37702.n0 6.75196
R3719 a_43000_n37702.n2 a_43000_n37702.t1 5.9772
R3720 a_43000_n37702.n0 a_43000_n37702.t3 5.9772
R3721 a_43000_n37702.n0 a_43000_n37702.t4 5.9772
R3722 a_43000_n37702.t2 a_43000_n37702.n2 5.9772
R3723 a_40000_n37702.n1 a_40000_n37702.t0 19.0047
R3724 a_40000_n37702.n1 a_40000_n37702.n0 8.64669
R3725 a_40000_n37702.n2 a_40000_n37702.n1 6.75196
R3726 a_40000_n37702.n2 a_40000_n37702.t1 5.9772
R3727 a_40000_n37702.n0 a_40000_n37702.t3 5.9772
R3728 a_40000_n37702.n0 a_40000_n37702.t4 5.9772
R3729 a_40000_n37702.t2 a_40000_n37702.n2 5.9772
R3730 a_37000_n37702.n1 a_37000_n37702.t0 19.0047
R3731 a_37000_n37702.n1 a_37000_n37702.n0 8.64669
R3732 a_37000_n37702.n2 a_37000_n37702.n1 6.75196
R3733 a_37000_n37702.n2 a_37000_n37702.t1 5.9772
R3734 a_37000_n37702.n0 a_37000_n37702.t3 5.9772
R3735 a_37000_n37702.n0 a_37000_n37702.t4 5.9772
R3736 a_37000_n37702.t2 a_37000_n37702.n2 5.9772
R3737 a_34000_n37702.n1 a_34000_n37702.t2 19.0047
R3738 a_34000_n37702.n2 a_34000_n37702.n1 8.64669
R3739 a_34000_n37702.n1 a_34000_n37702.n0 6.75196
R3740 a_34000_n37702.n2 a_34000_n37702.t0 5.9772
R3741 a_34000_n37702.n0 a_34000_n37702.t3 5.9772
R3742 a_34000_n37702.n0 a_34000_n37702.t4 5.9772
R3743 a_34000_n37702.t1 a_34000_n37702.n2 5.9772
R3744 a_31000_n37702.n1 a_31000_n37702.t4 19.0047
R3745 a_31000_n37702.n1 a_31000_n37702.n0 8.64669
R3746 a_31000_n37702.n2 a_31000_n37702.n1 6.75196
R3747 a_31000_n37702.n2 a_31000_n37702.t0 5.9772
R3748 a_31000_n37702.n0 a_31000_n37702.t2 5.9772
R3749 a_31000_n37702.n0 a_31000_n37702.t3 5.9772
R3750 a_31000_n37702.t1 a_31000_n37702.n2 5.9772
R3751 a_24600_n37702.n1 a_24600_n37702.t2 19.0047
R3752 a_24600_n37702.n1 a_24600_n37702.n0 8.64669
R3753 a_24600_n37702.n2 a_24600_n37702.n1 6.75196
R3754 a_24600_n37702.n2 a_24600_n37702.t0 5.9772
R3755 a_24600_n37702.n0 a_24600_n37702.t3 5.9772
R3756 a_24600_n37702.n0 a_24600_n37702.t4 5.9772
R3757 a_24600_n37702.t1 a_24600_n37702.n2 5.9772
R3758 a_21600_n37702.n1 a_21600_n37702.t2 19.0047
R3759 a_21600_n37702.n2 a_21600_n37702.n1 8.64669
R3760 a_21600_n37702.n1 a_21600_n37702.n0 6.75196
R3761 a_21600_n37702.n2 a_21600_n37702.t0 5.9772
R3762 a_21600_n37702.n0 a_21600_n37702.t3 5.9772
R3763 a_21600_n37702.n0 a_21600_n37702.t4 5.9772
R3764 a_21600_n37702.t1 a_21600_n37702.n2 5.9772
R3765 a_18600_n37702.n1 a_18600_n37702.t4 19.0047
R3766 a_18600_n37702.n2 a_18600_n37702.n1 8.64669
R3767 a_18600_n37702.n1 a_18600_n37702.n0 6.75196
R3768 a_18600_n37702.n2 a_18600_n37702.t0 5.9772
R3769 a_18600_n37702.n0 a_18600_n37702.t2 5.9772
R3770 a_18600_n37702.n0 a_18600_n37702.t3 5.9772
R3771 a_18600_n37702.t1 a_18600_n37702.n2 5.9772
R3772 a_15600_n37702.n1 a_15600_n37702.t4 19.0047
R3773 a_15600_n37702.n2 a_15600_n37702.n1 8.64669
R3774 a_15600_n37702.n1 a_15600_n37702.n0 6.75196
R3775 a_15600_n37702.n2 a_15600_n37702.t0 5.9772
R3776 a_15600_n37702.n0 a_15600_n37702.t2 5.9772
R3777 a_15600_n37702.n0 a_15600_n37702.t3 5.9772
R3778 a_15600_n37702.t1 a_15600_n37702.n2 5.9772
R3779 a_12600_n37702.n1 a_12600_n37702.t4 19.0047
R3780 a_12600_n37702.n2 a_12600_n37702.n1 8.64669
R3781 a_12600_n37702.n1 a_12600_n37702.n0 6.75196
R3782 a_12600_n37702.n2 a_12600_n37702.t0 5.9772
R3783 a_12600_n37702.n0 a_12600_n37702.t2 5.9772
R3784 a_12600_n37702.n0 a_12600_n37702.t3 5.9772
R3785 a_12600_n37702.t1 a_12600_n37702.n2 5.9772
R3786 a_n13000_n37702.n1 a_n13000_n37702.t0 19.0047
R3787 a_n13000_n37702.n1 a_n13000_n37702.n0 8.64669
R3788 a_n13000_n37702.n2 a_n13000_n37702.n1 6.75196
R3789 a_n13000_n37702.n2 a_n13000_n37702.t1 5.9772
R3790 a_n13000_n37702.n0 a_n13000_n37702.t3 5.9772
R3791 a_n13000_n37702.n0 a_n13000_n37702.t4 5.9772
R3792 a_n13000_n37702.t2 a_n13000_n37702.n2 5.9772
R3793 a_n16000_n37702.n1 a_n16000_n37702.t2 19.0047
R3794 a_n16000_n37702.n2 a_n16000_n37702.n1 8.64669
R3795 a_n16000_n37702.n1 a_n16000_n37702.n0 6.75196
R3796 a_n16000_n37702.n2 a_n16000_n37702.t0 5.9772
R3797 a_n16000_n37702.n0 a_n16000_n37702.t3 5.9772
R3798 a_n16000_n37702.n0 a_n16000_n37702.t4 5.9772
R3799 a_n16000_n37702.t1 a_n16000_n37702.n2 5.9772
R3800 a_n19000_n37702.n1 a_n19000_n37702.t4 19.0047
R3801 a_n19000_n37702.n1 a_n19000_n37702.n0 8.64669
R3802 a_n19000_n37702.n2 a_n19000_n37702.n1 6.75196
R3803 a_n19000_n37702.n2 a_n19000_n37702.t0 5.9772
R3804 a_n19000_n37702.n0 a_n19000_n37702.t2 5.9772
R3805 a_n19000_n37702.n0 a_n19000_n37702.t3 5.9772
R3806 a_n19000_n37702.t1 a_n19000_n37702.n2 5.9772
R3807 a_n22000_n37702.n1 a_n22000_n37702.t0 19.0047
R3808 a_n22000_n37702.n1 a_n22000_n37702.n0 8.64669
R3809 a_n22000_n37702.n2 a_n22000_n37702.n1 6.75196
R3810 a_n22000_n37702.n2 a_n22000_n37702.t1 5.9772
R3811 a_n22000_n37702.n0 a_n22000_n37702.t3 5.9772
R3812 a_n22000_n37702.n0 a_n22000_n37702.t4 5.9772
R3813 a_n22000_n37702.t2 a_n22000_n37702.n2 5.9772
R3814 a_n25000_n37702.n1 a_n25000_n37702.t0 19.0047
R3815 a_n25000_n37702.n2 a_n25000_n37702.n1 8.64669
R3816 a_n25000_n37702.n1 a_n25000_n37702.n0 6.75196
R3817 a_n25000_n37702.n2 a_n25000_n37702.t1 5.9772
R3818 a_n25000_n37702.n0 a_n25000_n37702.t3 5.9772
R3819 a_n25000_n37702.n0 a_n25000_n37702.t4 5.9772
R3820 a_n25000_n37702.t2 a_n25000_n37702.n2 5.9772
R3821 a_n31400_n37702.n1 a_n31400_n37702.t0 19.0047
R3822 a_n31400_n37702.n2 a_n31400_n37702.n1 8.64669
R3823 a_n31400_n37702.n1 a_n31400_n37702.n0 6.75196
R3824 a_n31400_n37702.n2 a_n31400_n37702.t1 5.9772
R3825 a_n31400_n37702.n0 a_n31400_n37702.t3 5.9772
R3826 a_n31400_n37702.n0 a_n31400_n37702.t4 5.9772
R3827 a_n31400_n37702.t2 a_n31400_n37702.n2 5.9772
R3828 a_n34400_n37702.n1 a_n34400_n37702.t2 19.0047
R3829 a_n34400_n37702.n1 a_n34400_n37702.n0 8.64669
R3830 a_n34400_n37702.n2 a_n34400_n37702.n1 6.75196
R3831 a_n34400_n37702.n2 a_n34400_n37702.t0 5.9772
R3832 a_n34400_n37702.n0 a_n34400_n37702.t3 5.9772
R3833 a_n34400_n37702.n0 a_n34400_n37702.t4 5.9772
R3834 a_n34400_n37702.t1 a_n34400_n37702.n2 5.9772
R3835 a_n37400_n37702.n1 a_n37400_n37702.t2 19.0047
R3836 a_n37400_n37702.n2 a_n37400_n37702.n1 8.64669
R3837 a_n37400_n37702.n1 a_n37400_n37702.n0 6.75196
R3838 a_n37400_n37702.n2 a_n37400_n37702.t0 5.9772
R3839 a_n37400_n37702.n0 a_n37400_n37702.t3 5.9772
R3840 a_n37400_n37702.n0 a_n37400_n37702.t4 5.9772
R3841 a_n37400_n37702.t1 a_n37400_n37702.n2 5.9772
R3842 a_n40400_n37702.n1 a_n40400_n37702.t0 19.0047
R3843 a_n40400_n37702.n2 a_n40400_n37702.n1 8.64669
R3844 a_n40400_n37702.n1 a_n40400_n37702.n0 6.75196
R3845 a_n40400_n37702.n2 a_n40400_n37702.t1 5.9772
R3846 a_n40400_n37702.n0 a_n40400_n37702.t3 5.9772
R3847 a_n40400_n37702.n0 a_n40400_n37702.t4 5.9772
R3848 a_n40400_n37702.t2 a_n40400_n37702.n2 5.9772
R3849 a_n43400_n37702.n1 a_n43400_n37702.t0 19.0047
R3850 a_n43400_n37702.n1 a_n43400_n37702.n0 8.64669
R3851 a_n43400_n37702.n2 a_n43400_n37702.n1 6.75196
R3852 a_n43400_n37702.n2 a_n43400_n37702.t1 5.9772
R3853 a_n43400_n37702.n0 a_n43400_n37702.t3 5.9772
R3854 a_n43400_n37702.n0 a_n43400_n37702.t4 5.9772
R3855 a_n43400_n37702.t2 a_n43400_n37702.n2 5.9772
R3856 a_27028_n400.n0 a_27028_n400.t3 16.0424
R3857 a_27028_n400.n0 a_27028_n400.t0 14.8582
R3858 a_27028_n400.n1 a_27028_n400.n0 6.02323
R3859 a_27028_n400.n1 a_27028_n400.t1 5.95154
R3860 a_27028_n400.t2 a_27028_n400.n1 5.95154
R3861 a_24948_n500.n6 a_24948_n500.n4 19.8938
R3862 a_24948_n500.n6 a_24948_n500.n5 19.1827
R3863 a_24948_n500.t4 a_24948_n500.n13 5.60716
R3864 a_24948_n500.n2 a_24948_n500.t1 5.60716
R3865 a_24948_n500.n12 a_24948_n500.n1 5.44336
R3866 a_24948_n500.n7 a_24948_n500.n0 4.59466
R3867 a_24948_n500.n9 a_24948_n500.n8 4.58471
R3868 a_24948_n500.n10 a_24948_n500.n2 4.5005
R3869 a_24948_n500.n12 a_24948_n500.n11 4.5005
R3870 a_24948_n500.n13 a_24948_n500.n0 4.5005
R3871 a_24948_n500.n10 a_24948_n500.n9 4.5005
R3872 a_24948_n500.n11 a_24948_n500.n3 4.5005
R3873 a_24948_n500.n8 a_24948_n500.n7 2.22546
R3874 a_24948_n500.n8 a_24948_n500.n6 0.351553
R3875 a_24948_n500.n4 a_24948_n500.t7 0.3281
R3876 a_24948_n500.n4 a_24948_n500.t5 0.3281
R3877 a_24948_n500.n5 a_24948_n500.t0 0.3281
R3878 a_24948_n500.n5 a_24948_n500.t6 0.3281
R3879 a_24948_n500.n12 a_24948_n500.n2 0.189974
R3880 a_24948_n500.n13 a_24948_n500.n12 0.189974
R3881 a_24948_n500.n11 a_24948_n500.n10 0.189974
R3882 a_24948_n500.n11 a_24948_n500.n0 0.189974
R3883 a_24948_n500.n9 a_24948_n500.n3 0.189974
R3884 a_24948_n500.n1 a_24948_n500.t2 0.1643
R3885 a_24948_n500.n1 a_24948_n500.t3 0.1643
R3886 a_24948_n500.n7 a_24948_n500.n3 0.092941
R3887 a_n28972_n400.n0 a_n28972_n400.t2 16.0424
R3888 a_n28972_n400.n0 a_n28972_n400.t3 14.8582
R3889 a_n28972_n400.n1 a_n28972_n400.n0 5.90481
R3890 a_n28972_n400.n1 a_n28972_n400.t0 5.67287
R3891 a_n28972_n400.t1 a_n28972_n400.n1 5.67287
R3892 a_n31052_n500.n5 a_n31052_n500.n3 19.8938
R3893 a_n31052_n500.n5 a_n31052_n500.n4 19.1827
R3894 a_n31052_n500.n0 a_n31052_n500.t7 5.85122
R3895 a_n31052_n500.n11 a_n31052_n500.t4 5.85122
R3896 a_n31052_n500.n13 a_n31052_n500.n12 5.74202
R3897 a_n31052_n500.n7 a_n31052_n500.n6 4.59466
R3898 a_n31052_n500.n9 a_n31052_n500.n8 4.58471
R3899 a_n31052_n500.n11 a_n31052_n500.n10 4.5005
R3900 a_n31052_n500.n12 a_n31052_n500.n1 4.5005
R3901 a_n31052_n500.n6 a_n31052_n500.n0 4.5005
R3902 a_n31052_n500.n10 a_n31052_n500.n9 4.5005
R3903 a_n31052_n500.n2 a_n31052_n500.n1 4.5005
R3904 a_n31052_n500.n8 a_n31052_n500.n7 2.22546
R3905 a_n31052_n500.n3 a_n31052_n500.t3 0.3281
R3906 a_n31052_n500.n3 a_n31052_n500.t2 0.3281
R3907 a_n31052_n500.n4 a_n31052_n500.t0 0.3281
R3908 a_n31052_n500.n4 a_n31052_n500.t1 0.3281
R3909 a_n31052_n500.n8 a_n31052_n500.n5 0.219974
R3910 a_n31052_n500.n12 a_n31052_n500.n11 0.189974
R3911 a_n31052_n500.n12 a_n31052_n500.n0 0.189974
R3912 a_n31052_n500.n10 a_n31052_n500.n1 0.189974
R3913 a_n31052_n500.n6 a_n31052_n500.n1 0.189974
R3914 a_n31052_n500.n9 a_n31052_n500.n2 0.189974
R3915 a_n31052_n500.n13 a_n31052_n500.t5 0.1097
R3916 a_n31052_n500.t6 a_n31052_n500.n13 0.1097
R3917 a_n31052_n500.n7 a_n31052_n500.n2 0.092941
R3918 a_27028_12400.n0 a_27028_12400.t2 16.0424
R3919 a_27028_12400.n0 a_27028_12400.t3 14.8582
R3920 a_27028_12400.n1 a_27028_12400.n0 6.02323
R3921 a_27028_12400.n1 a_27028_12400.t0 5.95154
R3922 a_27028_12400.t1 a_27028_12400.n1 5.95154
R3923 XBANK.XGAIN.XSTART.NODEN.n6 XBANK.XGAIN.XSTART.NODEN.t5 96.4943
R3924 XBANK.XGAIN.XSTART.NODEN.n0 XBANK.XGAIN.XSTART.NODEN.t7 74.5104
R3925 XBANK.XGAIN.XSTART.NODEN.n0 XBANK.XGAIN.XSTART.NODEN.t8 74.5104
R3926 XBANK.XGAIN.XSTART.NODEN.n2 XBANK.XGAIN.XSTART.NODEN.t6 35.6252
R3927 XBANK.XGAIN.XSTART.NODEN.n6 XBANK.XGAIN.XSTART.NODEN.t4 31.3566
R3928 XBANK.XGAIN.XSTART.NODEN XBANK.XGAIN.XSTART.NODEN.n0 26.0508
R3929 XBANK.XGAIN.XSTART.NODEN XBANK.XGAIN.XSTART.NODEN.t2 19.0295
R3930 XBANK.XGAIN.XSTART.NODEN.n1 XBANK.XGAIN.XSTART.NODEN 17.29
R3931 XBANK.XGAIN.XSTART.NODEN.n1 XBANK.XGAIN.XSTART.NODEN 15.2439
R3932 XBANK.XGAIN.XSTART.NODEN.n6 XBANK.XGAIN.XSTART.NODEN.t0 11.0041
R3933 XBANK.XGAIN.XSTART.NODEN.n2 XBANK.XGAIN.XSTART.NODEN.n1 6.15839
R3934 XBANK.XGAIN.XSTART.NODEN.n3 XBANK.XGAIN.XSTART.NODEN.t1 5.69917
R3935 XBANK.XGAIN.XSTART.NODEN.n4 XBANK.XGAIN.XSTART.NODEN.t3 5.69917
R3936 XBANK.XGAIN.XSTART.NODEN.n3 XBANK.XGAIN.XSTART.NODEN.n2 4.5805
R3937 XBANK.XGAIN.XSTART.NODEN.n5 XBANK.XGAIN.XSTART.NODEN.n4 4.5005
R3938 XBANK.XGAIN.XSTART.NODEN.n4 XBANK.XGAIN.XSTART.NODEN.n3 0.189974
R3939 XBANK.XGAIN.XSTART.NODEN XBANK.XGAIN.XSTART.NODEN.n5 0.1705
R3940 XBANK.XGAIN.XSTART.NODEN XBANK.XGAIN.XSTART.NODEN.n6 0.1505
R3941 XBANK.XGAIN.XSTART.NODEN.n5 XBANK.XGAIN.XSTART.NODEN.n2 0.0805
R3942 a_24948_12300.n6 a_24948_12300.n4 19.8938
R3943 a_24948_12300.n6 a_24948_12300.n5 19.1827
R3944 a_24948_12300.t6 a_24948_12300.n13 5.60716
R3945 a_24948_12300.n2 a_24948_12300.t3 5.60716
R3946 a_24948_12300.n12 a_24948_12300.n1 5.44336
R3947 a_24948_12300.n7 a_24948_12300.n0 4.59466
R3948 a_24948_12300.n9 a_24948_12300.n8 4.58471
R3949 a_24948_12300.n10 a_24948_12300.n2 4.5005
R3950 a_24948_12300.n12 a_24948_12300.n11 4.5005
R3951 a_24948_12300.n13 a_24948_12300.n0 4.5005
R3952 a_24948_12300.n10 a_24948_12300.n9 4.5005
R3953 a_24948_12300.n11 a_24948_12300.n3 4.5005
R3954 a_24948_12300.n8 a_24948_12300.n7 2.22546
R3955 a_24948_12300.n8 a_24948_12300.n6 0.351553
R3956 a_24948_12300.n4 a_24948_12300.t2 0.3281
R3957 a_24948_12300.n4 a_24948_12300.t1 0.3281
R3958 a_24948_12300.n5 a_24948_12300.t7 0.3281
R3959 a_24948_12300.n5 a_24948_12300.t0 0.3281
R3960 a_24948_12300.n12 a_24948_12300.n2 0.189974
R3961 a_24948_12300.n13 a_24948_12300.n12 0.189974
R3962 a_24948_12300.n11 a_24948_12300.n10 0.189974
R3963 a_24948_12300.n11 a_24948_12300.n0 0.189974
R3964 a_24948_12300.n9 a_24948_12300.n3 0.189974
R3965 a_24948_12300.n1 a_24948_12300.t4 0.1643
R3966 a_24948_12300.n1 a_24948_12300.t5 0.1643
R3967 a_24948_12300.n7 a_24948_12300.n3 0.092941
R3968 XBANK.XGAIN.XSTART.NODEP.n3 XBANK.XGAIN.XSTART.NODEP.t5 94.691
R3969 XBANK.XGAIN.XSTART.NODEP.n0 XBANK.XGAIN.XSTART.NODEP.t7 74.5104
R3970 XBANK.XGAIN.XSTART.NODEP.n0 XBANK.XGAIN.XSTART.NODEP.t8 74.5104
R3971 XBANK.XGAIN.XSTART.NODEP.n2 XBANK.XGAIN.XSTART.NODEP.t6 35.6252
R3972 XBANK.XGAIN.XSTART.NODEP XBANK.XGAIN.XSTART.NODEP.n0 26.0508
R3973 XBANK.XGAIN.XSTART.NODEP.n3 XBANK.XGAIN.XSTART.NODEP.t1 21.9418
R3974 XBANK.XGAIN.XSTART.NODEP XBANK.XGAIN.XSTART.NODEP.t4 19.1124
R3975 XBANK.XGAIN.XSTART.NODEP.n1 XBANK.XGAIN.XSTART.NODEP 17.29
R3976 XBANK.XGAIN.XSTART.NODEP.n1 XBANK.XGAIN.XSTART.NODEP 15.0663
R3977 XBANK.XGAIN.XSTART.NODEP.n4 XBANK.XGAIN.XSTART.NODEP.t2 10.9241
R3978 XBANK.XGAIN.XSTART.NODEP.n2 XBANK.XGAIN.XSTART.NODEP.n1 6.15839
R3979 XBANK.XGAIN.XSTART.NODEP.n7 XBANK.XGAIN.XSTART.NODEP.t0 5.69917
R3980 XBANK.XGAIN.XSTART.NODEP.n6 XBANK.XGAIN.XSTART.NODEP.t3 5.69917
R3981 XBANK.XGAIN.XSTART.NODEP.n4 XBANK.XGAIN.XSTART.NODEP.n3 4.80115
R3982 XBANK.XGAIN.XSTART.NODEP.n8 XBANK.XGAIN.XSTART.NODEP.n7 4.5005
R3983 XBANK.XGAIN.XSTART.NODEP.n6 XBANK.XGAIN.XSTART.NODEP.n5 4.5005
R3984 XBANK.XGAIN.XSTART.NODEP.n5 XBANK.XGAIN.XSTART.NODEP.n4 0.3205
R3985 XBANK.XGAIN.XSTART.NODEP.n7 XBANK.XGAIN.XSTART.NODEP.n6 0.189974
R3986 XBANK.XGAIN.XSTART.NODEP.n8 XBANK.XGAIN.XSTART.NODEP.n2 0.0805
R3987 XBANK.XGAIN.XSTART.NODEP.n5 XBANK.XGAIN.XSTART.NODEP.n2 0.0805
R3988 XBANK.XGAIN.XSTART.NODEP XBANK.XGAIN.XSTART.NODEP.n8 0.0405
R3989 a_n28972_12400.n0 a_n28972_12400.t2 16.0424
R3990 a_n28972_12400.n0 a_n28972_12400.t3 14.8582
R3991 a_n28972_12400.n1 a_n28972_12400.n0 5.90481
R3992 a_n28972_12400.n1 a_n28972_12400.t0 5.67287
R3993 a_n28972_12400.t1 a_n28972_12400.n1 5.67287
R3994 XBANK.XFAST.XSTART.NODEN.n6 XBANK.XFAST.XSTART.NODEN.t5 96.4943
R3995 XBANK.XFAST.XSTART.NODEN.n0 XBANK.XFAST.XSTART.NODEN.t7 74.5104
R3996 XBANK.XFAST.XSTART.NODEN.n0 XBANK.XFAST.XSTART.NODEN.t8 74.5104
R3997 XBANK.XFAST.XSTART.NODEN.n2 XBANK.XFAST.XSTART.NODEN.t6 31.5274
R3998 XBANK.XFAST.XSTART.NODEN.n6 XBANK.XFAST.XSTART.NODEN.t1 31.4224
R3999 XBANK.XFAST.XSTART.NODEN XBANK.XFAST.XSTART.NODEN.n0 26.0508
R4000 XBANK.XFAST.XSTART.NODEN XBANK.XFAST.XSTART.NODEN.t0 19.0295
R4001 XBANK.XFAST.XSTART.NODEN.n1 XBANK.XFAST.XSTART.NODEN 17.29
R4002 XBANK.XFAST.XSTART.NODEN.n1 XBANK.XFAST.XSTART.NODEN 15.2439
R4003 XBANK.XFAST.XSTART.NODEN.n6 XBANK.XFAST.XSTART.NODEN.t2 11.0041
R4004 XBANK.XFAST.XSTART.NODEN.n2 XBANK.XFAST.XSTART.NODEN.n1 6.15839
R4005 XBANK.XFAST.XSTART.NODEN.n3 XBANK.XFAST.XSTART.NODEN.t3 5.69917
R4006 XBANK.XFAST.XSTART.NODEN.n4 XBANK.XFAST.XSTART.NODEN.t4 5.69917
R4007 XBANK.XFAST.XSTART.NODEN.n3 XBANK.XFAST.XSTART.NODEN.n2 4.5805
R4008 XBANK.XFAST.XSTART.NODEN.n5 XBANK.XFAST.XSTART.NODEN.n4 4.5005
R4009 XBANK.XFAST.XSTART.NODEN.n4 XBANK.XFAST.XSTART.NODEN.n3 0.189974
R4010 XBANK.XFAST.XSTART.NODEN XBANK.XFAST.XSTART.NODEN.n5 0.1705
R4011 XBANK.XFAST.XSTART.NODEN XBANK.XFAST.XSTART.NODEN.n6 0.1505
R4012 XBANK.XFAST.XSTART.NODEN.n5 XBANK.XFAST.XSTART.NODEN.n2 0.0805
R4013 a_n31052_12300.n5 a_n31052_12300.n3 19.8938
R4014 a_n31052_12300.n5 a_n31052_12300.n4 19.1827
R4015 a_n31052_12300.n0 a_n31052_12300.t7 5.85122
R4016 a_n31052_12300.n11 a_n31052_12300.t4 5.85122
R4017 a_n31052_12300.n13 a_n31052_12300.n12 5.74202
R4018 a_n31052_12300.n7 a_n31052_12300.n6 4.59466
R4019 a_n31052_12300.n9 a_n31052_12300.n8 4.58471
R4020 a_n31052_12300.n11 a_n31052_12300.n10 4.5005
R4021 a_n31052_12300.n12 a_n31052_12300.n1 4.5005
R4022 a_n31052_12300.n6 a_n31052_12300.n0 4.5005
R4023 a_n31052_12300.n10 a_n31052_12300.n9 4.5005
R4024 a_n31052_12300.n2 a_n31052_12300.n1 4.5005
R4025 a_n31052_12300.n8 a_n31052_12300.n7 2.22546
R4026 a_n31052_12300.n3 a_n31052_12300.t3 0.3281
R4027 a_n31052_12300.n3 a_n31052_12300.t2 0.3281
R4028 a_n31052_12300.n4 a_n31052_12300.t0 0.3281
R4029 a_n31052_12300.n4 a_n31052_12300.t1 0.3281
R4030 a_n31052_12300.n8 a_n31052_12300.n5 0.219974
R4031 a_n31052_12300.n12 a_n31052_12300.n11 0.189974
R4032 a_n31052_12300.n12 a_n31052_12300.n0 0.189974
R4033 a_n31052_12300.n10 a_n31052_12300.n1 0.189974
R4034 a_n31052_12300.n6 a_n31052_12300.n1 0.189974
R4035 a_n31052_12300.n9 a_n31052_12300.n2 0.189974
R4036 a_n31052_12300.n13 a_n31052_12300.t5 0.1097
R4037 a_n31052_12300.t6 a_n31052_12300.n13 0.1097
R4038 a_n31052_12300.n7 a_n31052_12300.n2 0.092941
R4039 XBANK.XFAST.XSTART.NODEP.n3 XBANK.XFAST.XSTART.NODEP.t5 94.691
R4040 XBANK.XFAST.XSTART.NODEP.n0 XBANK.XFAST.XSTART.NODEP.t7 74.5104
R4041 XBANK.XFAST.XSTART.NODEP.n0 XBANK.XFAST.XSTART.NODEP.t8 74.5104
R4042 XBANK.XFAST.XSTART.NODEP.n2 XBANK.XFAST.XSTART.NODEP.t6 31.5274
R4043 XBANK.XFAST.XSTART.NODEP XBANK.XFAST.XSTART.NODEP.n0 26.0508
R4044 XBANK.XFAST.XSTART.NODEP.n3 XBANK.XFAST.XSTART.NODEP.t2 22.0076
R4045 XBANK.XFAST.XSTART.NODEP XBANK.XFAST.XSTART.NODEP.t3 19.1124
R4046 XBANK.XFAST.XSTART.NODEP.n1 XBANK.XFAST.XSTART.NODEP 17.29
R4047 XBANK.XFAST.XSTART.NODEP.n1 XBANK.XFAST.XSTART.NODEP 15.0663
R4048 XBANK.XFAST.XSTART.NODEP.n4 XBANK.XFAST.XSTART.NODEP.t4 10.9241
R4049 XBANK.XFAST.XSTART.NODEP.n2 XBANK.XFAST.XSTART.NODEP.n1 6.15839
R4050 XBANK.XFAST.XSTART.NODEP.n7 XBANK.XFAST.XSTART.NODEP.t0 5.69917
R4051 XBANK.XFAST.XSTART.NODEP.n6 XBANK.XFAST.XSTART.NODEP.t1 5.69917
R4052 XBANK.XFAST.XSTART.NODEP.n4 XBANK.XFAST.XSTART.NODEP.n3 4.80115
R4053 XBANK.XFAST.XSTART.NODEP.n8 XBANK.XFAST.XSTART.NODEP.n7 4.5005
R4054 XBANK.XFAST.XSTART.NODEP.n6 XBANK.XFAST.XSTART.NODEP.n5 4.5005
R4055 XBANK.XFAST.XSTART.NODEP.n5 XBANK.XFAST.XSTART.NODEP.n4 0.3205
R4056 XBANK.XFAST.XSTART.NODEP.n7 XBANK.XFAST.XSTART.NODEP.n6 0.189974
R4057 XBANK.XFAST.XSTART.NODEP.n8 XBANK.XFAST.XSTART.NODEP.n2 0.0805
R4058 XBANK.XFAST.XSTART.NODEP.n5 XBANK.XFAST.XSTART.NODEP.n2 0.0805
R4059 XBANK.XFAST.XSTART.NODEP XBANK.XFAST.XSTART.NODEP.n8 0.0405
R4060 a_27028_25200.n0 a_27028_25200.t0 16.0424
R4061 a_27028_25200.n0 a_27028_25200.t3 14.8582
R4062 a_27028_25200.n1 a_27028_25200.n0 6.02323
R4063 a_27028_25200.n1 a_27028_25200.t1 5.95154
R4064 a_27028_25200.t2 a_27028_25200.n1 5.95154
R4065 XBANK.XGAIN.X2.INN.n5 XBANK.XGAIN.X2.INN.t4 96.4943
R4066 XBANK.XGAIN.X2.INN.n0 XBANK.XGAIN.X2.INN.t6 74.5104
R4067 XBANK.XGAIN.X2.INN.n0 XBANK.XGAIN.X2.INN.t7 74.5104
R4068 XBANK.XGAIN.X2.INN.n1 XBANK.XGAIN.X2.INN.t5 35.6252
R4069 XBANK.XGAIN.X2.INN.n5 XBANK.XGAIN.X2.INN.t2 31.3566
R4070 XBANK.XGAIN.X2.INN XBANK.XGAIN.X2.INN.n0 26.0508
R4071 XBANK.XGAIN.X2.INN.n1 XBANK.XGAIN.X2.INN 23.4479
R4072 XBANK.XGAIN.X2.INN.n5 XBANK.XGAIN.X2.INN.t3 11.0041
R4073 XBANK.XGAIN.X2.INN.n2 XBANK.XGAIN.X2.INN.t1 5.69917
R4074 XBANK.XGAIN.X2.INN.n3 XBANK.XGAIN.X2.INN.t0 5.69917
R4075 XBANK.XGAIN.X2.INN.n2 XBANK.XGAIN.X2.INN.n1 4.5805
R4076 XBANK.XGAIN.X2.INN.n4 XBANK.XGAIN.X2.INN.n3 4.5005
R4077 XBANK.XGAIN.X2.INN.n3 XBANK.XGAIN.X2.INN.n2 0.189974
R4078 XBANK.XGAIN.X2.INN XBANK.XGAIN.X2.INN.n4 0.1705
R4079 XBANK.XGAIN.X2.INN XBANK.XGAIN.X2.INN.n5 0.1505
R4080 XBANK.XGAIN.X2.INN.n4 XBANK.XGAIN.X2.INN.n1 0.0805
R4081 a_24948_25100.n6 a_24948_25100.n4 19.8938
R4082 a_24948_25100.n6 a_24948_25100.n5 19.1827
R4083 a_24948_25100.t5 a_24948_25100.n13 5.60716
R4084 a_24948_25100.n2 a_24948_25100.t2 5.60716
R4085 a_24948_25100.n12 a_24948_25100.n1 5.44336
R4086 a_24948_25100.n7 a_24948_25100.n0 4.59466
R4087 a_24948_25100.n9 a_24948_25100.n8 4.58471
R4088 a_24948_25100.n10 a_24948_25100.n2 4.5005
R4089 a_24948_25100.n12 a_24948_25100.n11 4.5005
R4090 a_24948_25100.n13 a_24948_25100.n0 4.5005
R4091 a_24948_25100.n10 a_24948_25100.n9 4.5005
R4092 a_24948_25100.n11 a_24948_25100.n3 4.5005
R4093 a_24948_25100.n8 a_24948_25100.n7 2.22546
R4094 a_24948_25100.n8 a_24948_25100.n6 0.351553
R4095 a_24948_25100.n4 a_24948_25100.t0 0.3281
R4096 a_24948_25100.n4 a_24948_25100.t1 0.3281
R4097 a_24948_25100.n5 a_24948_25100.t6 0.3281
R4098 a_24948_25100.n5 a_24948_25100.t7 0.3281
R4099 a_24948_25100.n12 a_24948_25100.n2 0.189974
R4100 a_24948_25100.n13 a_24948_25100.n12 0.189974
R4101 a_24948_25100.n11 a_24948_25100.n10 0.189974
R4102 a_24948_25100.n11 a_24948_25100.n0 0.189974
R4103 a_24948_25100.n9 a_24948_25100.n3 0.189974
R4104 a_24948_25100.n1 a_24948_25100.t3 0.1643
R4105 a_24948_25100.n1 a_24948_25100.t4 0.1643
R4106 a_24948_25100.n7 a_24948_25100.n3 0.092941
R4107 XBANK.XGAIN.X2.INP.n2 XBANK.XGAIN.X2.INP.t4 94.691
R4108 XBANK.XGAIN.X2.INP.n0 XBANK.XGAIN.X2.INP.t6 74.5104
R4109 XBANK.XGAIN.X2.INP.n0 XBANK.XGAIN.X2.INP.t7 74.5104
R4110 XBANK.XGAIN.X2.INP.n1 XBANK.XGAIN.X2.INP.t5 35.6252
R4111 XBANK.XGAIN.X2.INP XBANK.XGAIN.X2.INP.n0 26.0508
R4112 XBANK.XGAIN.X2.INP.n1 XBANK.XGAIN.X2.INP 23.4479
R4113 XBANK.XGAIN.X2.INP.n2 XBANK.XGAIN.X2.INP.t3 21.9418
R4114 XBANK.XGAIN.X2.INP.n3 XBANK.XGAIN.X2.INP.t0 10.9241
R4115 XBANK.XGAIN.X2.INP.n5 XBANK.XGAIN.X2.INP.t2 5.69917
R4116 XBANK.XGAIN.X2.INP.n6 XBANK.XGAIN.X2.INP.t1 5.69917
R4117 XBANK.XGAIN.X2.INP.n3 XBANK.XGAIN.X2.INP.n2 4.80115
R4118 XBANK.XGAIN.X2.INP.n7 XBANK.XGAIN.X2.INP.n6 4.5005
R4119 XBANK.XGAIN.X2.INP.n5 XBANK.XGAIN.X2.INP.n4 4.5005
R4120 XBANK.XGAIN.X2.INP.n4 XBANK.XGAIN.X2.INP.n3 0.3205
R4121 XBANK.XGAIN.X2.INP.n6 XBANK.XGAIN.X2.INP.n5 0.189974
R4122 XBANK.XGAIN.X2.INP.n7 XBANK.XGAIN.X2.INP.n1 0.0805
R4123 XBANK.XGAIN.X2.INP.n4 XBANK.XGAIN.X2.INP.n1 0.0805
R4124 XBANK.XGAIN.X2.INP XBANK.XGAIN.X2.INP.n7 0.0405
R4125 a_n28972_25200.n0 a_n28972_25200.t3 16.0424
R4126 a_n28972_25200.n0 a_n28972_25200.t2 14.8582
R4127 a_n28972_25200.n1 a_n28972_25200.n0 5.90481
R4128 a_n28972_25200.n1 a_n28972_25200.t0 5.67287
R4129 a_n28972_25200.t1 a_n28972_25200.n1 5.67287
R4130 XBANK.XFAST.X2.INN.n5 XBANK.XFAST.X2.INN.t4 96.4943
R4131 XBANK.XFAST.X2.INN.n0 XBANK.XFAST.X2.INN.t6 74.5104
R4132 XBANK.XFAST.X2.INN.n0 XBANK.XFAST.X2.INN.t7 74.5104
R4133 XBANK.XFAST.X2.INN.n1 XBANK.XFAST.X2.INN.t5 31.5274
R4134 XBANK.XFAST.X2.INN.n5 XBANK.XFAST.X2.INN.t0 31.4224
R4135 XBANK.XFAST.X2.INN XBANK.XFAST.X2.INN.n0 26.0508
R4136 XBANK.XFAST.X2.INN.n1 XBANK.XFAST.X2.INN 23.4479
R4137 XBANK.XFAST.X2.INN.n5 XBANK.XFAST.X2.INN.t1 11.0041
R4138 XBANK.XFAST.X2.INN.n2 XBANK.XFAST.X2.INN.t3 5.69917
R4139 XBANK.XFAST.X2.INN.n3 XBANK.XFAST.X2.INN.t2 5.69917
R4140 XBANK.XFAST.X2.INN.n2 XBANK.XFAST.X2.INN.n1 4.5805
R4141 XBANK.XFAST.X2.INN.n4 XBANK.XFAST.X2.INN.n3 4.5005
R4142 XBANK.XFAST.X2.INN.n3 XBANK.XFAST.X2.INN.n2 0.189974
R4143 XBANK.XFAST.X2.INN XBANK.XFAST.X2.INN.n4 0.1705
R4144 XBANK.XFAST.X2.INN XBANK.XFAST.X2.INN.n5 0.1505
R4145 XBANK.XFAST.X2.INN.n4 XBANK.XFAST.X2.INN.n1 0.0805
R4146 a_n31052_25100.n5 a_n31052_25100.n3 19.8938
R4147 a_n31052_25100.n5 a_n31052_25100.n4 19.1827
R4148 a_n31052_25100.n0 a_n31052_25100.t7 5.85122
R4149 a_n31052_25100.n11 a_n31052_25100.t4 5.85122
R4150 a_n31052_25100.n13 a_n31052_25100.n12 5.74202
R4151 a_n31052_25100.n7 a_n31052_25100.n6 4.59466
R4152 a_n31052_25100.n9 a_n31052_25100.n8 4.58471
R4153 a_n31052_25100.n11 a_n31052_25100.n10 4.5005
R4154 a_n31052_25100.n12 a_n31052_25100.n1 4.5005
R4155 a_n31052_25100.n6 a_n31052_25100.n0 4.5005
R4156 a_n31052_25100.n10 a_n31052_25100.n9 4.5005
R4157 a_n31052_25100.n2 a_n31052_25100.n1 4.5005
R4158 a_n31052_25100.n8 a_n31052_25100.n7 2.22546
R4159 a_n31052_25100.n3 a_n31052_25100.t0 0.3281
R4160 a_n31052_25100.n3 a_n31052_25100.t1 0.3281
R4161 a_n31052_25100.n4 a_n31052_25100.t3 0.3281
R4162 a_n31052_25100.n4 a_n31052_25100.t2 0.3281
R4163 a_n31052_25100.n8 a_n31052_25100.n5 0.219974
R4164 a_n31052_25100.n12 a_n31052_25100.n11 0.189974
R4165 a_n31052_25100.n12 a_n31052_25100.n0 0.189974
R4166 a_n31052_25100.n10 a_n31052_25100.n1 0.189974
R4167 a_n31052_25100.n6 a_n31052_25100.n1 0.189974
R4168 a_n31052_25100.n9 a_n31052_25100.n2 0.189974
R4169 a_n31052_25100.n13 a_n31052_25100.t5 0.1097
R4170 a_n31052_25100.t6 a_n31052_25100.n13 0.1097
R4171 a_n31052_25100.n7 a_n31052_25100.n2 0.092941
R4172 XBANK.XFAST.X2.INP.n2 XBANK.XFAST.X2.INP.t4 94.691
R4173 XBANK.XFAST.X2.INP.n0 XBANK.XFAST.X2.INP.t6 74.5104
R4174 XBANK.XFAST.X2.INP.n0 XBANK.XFAST.X2.INP.t7 74.5104
R4175 XBANK.XFAST.X2.INP.n1 XBANK.XFAST.X2.INP.t5 31.5274
R4176 XBANK.XFAST.X2.INP XBANK.XFAST.X2.INP.n0 26.0508
R4177 XBANK.XFAST.X2.INP.n1 XBANK.XFAST.X2.INP 23.4479
R4178 XBANK.XFAST.X2.INP.n2 XBANK.XFAST.X2.INP.t3 22.0076
R4179 XBANK.XFAST.X2.INP.n3 XBANK.XFAST.X2.INP.t2 10.9241
R4180 XBANK.XFAST.X2.INP.n5 XBANK.XFAST.X2.INP.t1 5.69917
R4181 XBANK.XFAST.X2.INP.n6 XBANK.XFAST.X2.INP.t0 5.69917
R4182 XBANK.XFAST.X2.INP.n3 XBANK.XFAST.X2.INP.n2 4.80115
R4183 XBANK.XFAST.X2.INP.n7 XBANK.XFAST.X2.INP.n6 4.5005
R4184 XBANK.XFAST.X2.INP.n5 XBANK.XFAST.X2.INP.n4 4.5005
R4185 XBANK.XFAST.X2.INP.n4 XBANK.XFAST.X2.INP.n3 0.3205
R4186 XBANK.XFAST.X2.INP.n6 XBANK.XFAST.X2.INP.n5 0.189974
R4187 XBANK.XFAST.X2.INP.n7 XBANK.XFAST.X2.INP.n1 0.0805
R4188 XBANK.XFAST.X2.INP.n4 XBANK.XFAST.X2.INP.n1 0.0805
R4189 XBANK.XFAST.X2.INP XBANK.XFAST.X2.INP.n7 0.0405
R4190 a_27028_38000.n0 a_27028_38000.t0 16.0424
R4191 a_27028_38000.n0 a_27028_38000.t1 14.8582
R4192 a_27028_38000.n1 a_27028_38000.n0 6.02323
R4193 a_27028_38000.n1 a_27028_38000.t3 5.95154
R4194 a_27028_38000.t2 a_27028_38000.n1 5.95154
R4195 XBANK.XGAIN.XBUF.INN.n7 XBANK.XGAIN.XBUF.INN.t6 96.4943
R4196 XBANK.XGAIN.XBUF.INN.n1 XBANK.XGAIN.XBUF.INN.t8 74.5104
R4197 XBANK.XGAIN.XBUF.INN.n1 XBANK.XGAIN.XBUF.INN.t9 74.5104
R4198 XBANK.XGAIN.XBUF.INN.n0 XBANK.XGAIN.XBUF.INN.t4 74.5104
R4199 XBANK.XGAIN.XBUF.INN.n0 XBANK.XGAIN.XBUF.INN.t5 74.5104
R4200 XBANK.XGAIN.XBUF.INN.n3 XBANK.XGAIN.XBUF.INN.t7 35.6252
R4201 XBANK.XGAIN.XBUF.INN.n7 XBANK.XGAIN.XBUF.INN.t2 31.3566
R4202 XBANK.XGAIN.XBUF.INN XBANK.XGAIN.XBUF.INN.n1 26.0508
R4203 XBANK.XGAIN.XBUF.INN XBANK.XGAIN.XBUF.INN.n0 26.0508
R4204 XBANK.XGAIN.XBUF.INN.n2 XBANK.XGAIN.XBUF.INN 24.711
R4205 XBANK.XGAIN.XBUF.INN.n2 XBANK.XGAIN.XBUF.INN 17.29
R4206 XBANK.XGAIN.XBUF.INN.n7 XBANK.XGAIN.XBUF.INN.t3 11.0041
R4207 XBANK.XGAIN.XBUF.INN.n3 XBANK.XGAIN.XBUF.INN.n2 6.15839
R4208 XBANK.XGAIN.XBUF.INN.n4 XBANK.XGAIN.XBUF.INN.t1 5.69917
R4209 XBANK.XGAIN.XBUF.INN.n5 XBANK.XGAIN.XBUF.INN.t0 5.69917
R4210 XBANK.XGAIN.XBUF.INN.n4 XBANK.XGAIN.XBUF.INN.n3 4.5805
R4211 XBANK.XGAIN.XBUF.INN.n6 XBANK.XGAIN.XBUF.INN.n5 4.5005
R4212 XBANK.XGAIN.XBUF.INN.n5 XBANK.XGAIN.XBUF.INN.n4 0.189974
R4213 XBANK.XGAIN.XBUF.INN XBANK.XGAIN.XBUF.INN.n6 0.1705
R4214 XBANK.XGAIN.XBUF.INN XBANK.XGAIN.XBUF.INN.n7 0.1505
R4215 XBANK.XGAIN.XBUF.INN.n6 XBANK.XGAIN.XBUF.INN.n3 0.0805
R4216 a_24948_37900.n6 a_24948_37900.n4 19.8938
R4217 a_24948_37900.n6 a_24948_37900.n5 19.1827
R4218 a_24948_37900.t3 a_24948_37900.n13 5.60716
R4219 a_24948_37900.n2 a_24948_37900.t0 5.60716
R4220 a_24948_37900.n12 a_24948_37900.n1 5.44336
R4221 a_24948_37900.n7 a_24948_37900.n0 4.59466
R4222 a_24948_37900.n9 a_24948_37900.n8 4.58471
R4223 a_24948_37900.n10 a_24948_37900.n2 4.5005
R4224 a_24948_37900.n12 a_24948_37900.n11 4.5005
R4225 a_24948_37900.n13 a_24948_37900.n0 4.5005
R4226 a_24948_37900.n10 a_24948_37900.n9 4.5005
R4227 a_24948_37900.n11 a_24948_37900.n3 4.5005
R4228 a_24948_37900.n8 a_24948_37900.n7 2.22546
R4229 a_24948_37900.n8 a_24948_37900.n6 0.351553
R4230 a_24948_37900.n4 a_24948_37900.t6 0.3281
R4231 a_24948_37900.n4 a_24948_37900.t5 0.3281
R4232 a_24948_37900.n5 a_24948_37900.t4 0.3281
R4233 a_24948_37900.n5 a_24948_37900.t7 0.3281
R4234 a_24948_37900.n12 a_24948_37900.n2 0.189974
R4235 a_24948_37900.n13 a_24948_37900.n12 0.189974
R4236 a_24948_37900.n11 a_24948_37900.n10 0.189974
R4237 a_24948_37900.n11 a_24948_37900.n0 0.189974
R4238 a_24948_37900.n9 a_24948_37900.n3 0.189974
R4239 a_24948_37900.n1 a_24948_37900.t1 0.1643
R4240 a_24948_37900.n1 a_24948_37900.t2 0.1643
R4241 a_24948_37900.n7 a_24948_37900.n3 0.092941
R4242 XBANK.XGAIN.XBUF.INP.n4 XBANK.XGAIN.XBUF.INP.t6 94.691
R4243 XBANK.XGAIN.XBUF.INP.n0 XBANK.XGAIN.XBUF.INP.t4 74.5104
R4244 XBANK.XGAIN.XBUF.INP.n0 XBANK.XGAIN.XBUF.INP.t5 74.5104
R4245 XBANK.XGAIN.XBUF.INP.n1 XBANK.XGAIN.XBUF.INP.t8 74.5104
R4246 XBANK.XGAIN.XBUF.INP.n1 XBANK.XGAIN.XBUF.INP.t9 74.5104
R4247 XBANK.XGAIN.XBUF.INP.n3 XBANK.XGAIN.XBUF.INP.t7 35.6252
R4248 XBANK.XGAIN.XBUF.INP XBANK.XGAIN.XBUF.INP.n0 26.0508
R4249 XBANK.XGAIN.XBUF.INP XBANK.XGAIN.XBUF.INP.n1 26.0508
R4250 XBANK.XGAIN.XBUF.INP.n2 XBANK.XGAIN.XBUF.INP 24.711
R4251 XBANK.XGAIN.XBUF.INP.n4 XBANK.XGAIN.XBUF.INP.t0 21.9418
R4252 XBANK.XGAIN.XBUF.INP.n2 XBANK.XGAIN.XBUF.INP 17.29
R4253 XBANK.XGAIN.XBUF.INP.n5 XBANK.XGAIN.XBUF.INP.t1 10.9241
R4254 XBANK.XGAIN.XBUF.INP.n3 XBANK.XGAIN.XBUF.INP.n2 6.15839
R4255 XBANK.XGAIN.XBUF.INP.n7 XBANK.XGAIN.XBUF.INP.t3 5.69917
R4256 XBANK.XGAIN.XBUF.INP.n8 XBANK.XGAIN.XBUF.INP.t2 5.69917
R4257 XBANK.XGAIN.XBUF.INP.n5 XBANK.XGAIN.XBUF.INP.n4 4.80115
R4258 XBANK.XGAIN.XBUF.INP.n9 XBANK.XGAIN.XBUF.INP.n8 4.5005
R4259 XBANK.XGAIN.XBUF.INP.n7 XBANK.XGAIN.XBUF.INP.n6 4.5005
R4260 XBANK.XGAIN.XBUF.INP.n6 XBANK.XGAIN.XBUF.INP.n5 0.3205
R4261 XBANK.XGAIN.XBUF.INP.n8 XBANK.XGAIN.XBUF.INP.n7 0.189974
R4262 XBANK.XGAIN.XBUF.INP.n9 XBANK.XGAIN.XBUF.INP.n3 0.0805
R4263 XBANK.XGAIN.XBUF.INP.n6 XBANK.XGAIN.XBUF.INP.n3 0.0805
R4264 XBANK.XGAIN.XBUF.INP XBANK.XGAIN.XBUF.INP.n9 0.0405
R4265 a_n28972_38000.n0 a_n28972_38000.t0 16.0424
R4266 a_n28972_38000.n0 a_n28972_38000.t3 14.8582
R4267 a_n28972_38000.n1 a_n28972_38000.n0 5.90481
R4268 a_n28972_38000.n1 a_n28972_38000.t1 5.67287
R4269 a_n28972_38000.t2 a_n28972_38000.n1 5.67287
R4270 XBANK.XFAST.XBUF.INN.n7 XBANK.XFAST.XBUF.INN.t6 96.4943
R4271 XBANK.XFAST.XBUF.INN.n1 XBANK.XFAST.XBUF.INN.t8 74.5104
R4272 XBANK.XFAST.XBUF.INN.n1 XBANK.XFAST.XBUF.INN.t9 74.5104
R4273 XBANK.XFAST.XBUF.INN.n0 XBANK.XFAST.XBUF.INN.t4 74.5104
R4274 XBANK.XFAST.XBUF.INN.n0 XBANK.XFAST.XBUF.INN.t5 74.5104
R4275 XBANK.XFAST.XBUF.INN.n3 XBANK.XFAST.XBUF.INN.t7 31.5274
R4276 XBANK.XFAST.XBUF.INN.n7 XBANK.XFAST.XBUF.INN.t0 31.4224
R4277 XBANK.XFAST.XBUF.INN XBANK.XFAST.XBUF.INN.n1 26.0508
R4278 XBANK.XFAST.XBUF.INN XBANK.XFAST.XBUF.INN.n0 26.0508
R4279 XBANK.XFAST.XBUF.INN.n2 XBANK.XFAST.XBUF.INN 24.711
R4280 XBANK.XFAST.XBUF.INN.n2 XBANK.XFAST.XBUF.INN 17.29
R4281 XBANK.XFAST.XBUF.INN.n7 XBANK.XFAST.XBUF.INN.t1 11.0041
R4282 XBANK.XFAST.XBUF.INN.n3 XBANK.XFAST.XBUF.INN.n2 6.15839
R4283 XBANK.XFAST.XBUF.INN.n4 XBANK.XFAST.XBUF.INN.t3 5.69917
R4284 XBANK.XFAST.XBUF.INN.n5 XBANK.XFAST.XBUF.INN.t2 5.69917
R4285 XBANK.XFAST.XBUF.INN.n4 XBANK.XFAST.XBUF.INN.n3 4.5805
R4286 XBANK.XFAST.XBUF.INN.n6 XBANK.XFAST.XBUF.INN.n5 4.5005
R4287 XBANK.XFAST.XBUF.INN.n5 XBANK.XFAST.XBUF.INN.n4 0.189974
R4288 XBANK.XFAST.XBUF.INN XBANK.XFAST.XBUF.INN.n6 0.1705
R4289 XBANK.XFAST.XBUF.INN XBANK.XFAST.XBUF.INN.n7 0.1505
R4290 XBANK.XFAST.XBUF.INN.n6 XBANK.XFAST.XBUF.INN.n3 0.0805
R4291 a_n31052_37900.n5 a_n31052_37900.n3 19.8938
R4292 a_n31052_37900.n5 a_n31052_37900.n4 19.1827
R4293 a_n31052_37900.n0 a_n31052_37900.t7 5.85122
R4294 a_n31052_37900.n11 a_n31052_37900.t4 5.85122
R4295 a_n31052_37900.n13 a_n31052_37900.n12 5.74202
R4296 a_n31052_37900.n7 a_n31052_37900.n6 4.59466
R4297 a_n31052_37900.n9 a_n31052_37900.n8 4.58471
R4298 a_n31052_37900.n11 a_n31052_37900.n10 4.5005
R4299 a_n31052_37900.n12 a_n31052_37900.n1 4.5005
R4300 a_n31052_37900.n6 a_n31052_37900.n0 4.5005
R4301 a_n31052_37900.n10 a_n31052_37900.n9 4.5005
R4302 a_n31052_37900.n2 a_n31052_37900.n1 4.5005
R4303 a_n31052_37900.n8 a_n31052_37900.n7 2.22546
R4304 a_n31052_37900.n3 a_n31052_37900.t2 0.3281
R4305 a_n31052_37900.n3 a_n31052_37900.t3 0.3281
R4306 a_n31052_37900.n4 a_n31052_37900.t1 0.3281
R4307 a_n31052_37900.n4 a_n31052_37900.t0 0.3281
R4308 a_n31052_37900.n8 a_n31052_37900.n5 0.219974
R4309 a_n31052_37900.n12 a_n31052_37900.n11 0.189974
R4310 a_n31052_37900.n12 a_n31052_37900.n0 0.189974
R4311 a_n31052_37900.n10 a_n31052_37900.n1 0.189974
R4312 a_n31052_37900.n6 a_n31052_37900.n1 0.189974
R4313 a_n31052_37900.n9 a_n31052_37900.n2 0.189974
R4314 a_n31052_37900.n13 a_n31052_37900.t5 0.1097
R4315 a_n31052_37900.t6 a_n31052_37900.n13 0.1097
R4316 a_n31052_37900.n7 a_n31052_37900.n2 0.092941
R4317 XBANK.XFAST.XBUF.INP.n4 XBANK.XFAST.XBUF.INP.t6 94.691
R4318 XBANK.XFAST.XBUF.INP.n0 XBANK.XFAST.XBUF.INP.t4 74.5104
R4319 XBANK.XFAST.XBUF.INP.n0 XBANK.XFAST.XBUF.INP.t5 74.5104
R4320 XBANK.XFAST.XBUF.INP.n1 XBANK.XFAST.XBUF.INP.t8 74.5104
R4321 XBANK.XFAST.XBUF.INP.n1 XBANK.XFAST.XBUF.INP.t9 74.5104
R4322 XBANK.XFAST.XBUF.INP.n3 XBANK.XFAST.XBUF.INP.t7 31.5274
R4323 XBANK.XFAST.XBUF.INP XBANK.XFAST.XBUF.INP.n0 26.0508
R4324 XBANK.XFAST.XBUF.INP XBANK.XFAST.XBUF.INP.n1 26.0508
R4325 XBANK.XFAST.XBUF.INP.n2 XBANK.XFAST.XBUF.INP 24.711
R4326 XBANK.XFAST.XBUF.INP.n4 XBANK.XFAST.XBUF.INP.t2 22.0076
R4327 XBANK.XFAST.XBUF.INP.n2 XBANK.XFAST.XBUF.INP 17.29
R4328 XBANK.XFAST.XBUF.INP.n5 XBANK.XFAST.XBUF.INP.t3 10.9241
R4329 XBANK.XFAST.XBUF.INP.n3 XBANK.XFAST.XBUF.INP.n2 6.15839
R4330 XBANK.XFAST.XBUF.INP.n7 XBANK.XFAST.XBUF.INP.t1 5.69917
R4331 XBANK.XFAST.XBUF.INP.n8 XBANK.XFAST.XBUF.INP.t0 5.69917
R4332 XBANK.XFAST.XBUF.INP.n5 XBANK.XFAST.XBUF.INP.n4 4.80115
R4333 XBANK.XFAST.XBUF.INP.n9 XBANK.XFAST.XBUF.INP.n8 4.5005
R4334 XBANK.XFAST.XBUF.INP.n7 XBANK.XFAST.XBUF.INP.n6 4.5005
R4335 XBANK.XFAST.XBUF.INP.n6 XBANK.XFAST.XBUF.INP.n5 0.3205
R4336 XBANK.XFAST.XBUF.INP.n8 XBANK.XFAST.XBUF.INP.n7 0.189974
R4337 XBANK.XFAST.XBUF.INP.n9 XBANK.XFAST.XBUF.INP.n3 0.0805
R4338 XBANK.XFAST.XBUF.INP.n6 XBANK.XFAST.XBUF.INP.n3 0.0805
R4339 XBANK.XFAST.XBUF.INP XBANK.XFAST.XBUF.INP.n9 0.0405
R4340 a_1748_53500.n5 a_1748_53500.n3 10.5451
R4341 a_1748_53500.n8 a_1748_53500.n6 10.5451
R4342 a_1748_53500.n5 a_1748_53500.n4 10.1451
R4343 a_1748_53500.n8 a_1748_53500.n7 10.1451
R4344 a_1748_53500.t7 a_1748_53500.n11 6.55182
R4345 a_1748_53500.n2 a_1748_53500.t4 6.45713
R4346 a_1748_53500.n1 a_1748_53500.n0 6.29333
R4347 a_1748_53500.n10 a_1748_53500.n2 4.63668
R4348 a_1748_53500.n11 a_1748_53500.n10 2.23814
R4349 a_1748_53500.n10 a_1748_53500.n9 0.6055
R4350 a_1748_53500.n3 a_1748_53500.t10 0.3281
R4351 a_1748_53500.n3 a_1748_53500.t9 0.3281
R4352 a_1748_53500.n4 a_1748_53500.t3 0.3281
R4353 a_1748_53500.n4 a_1748_53500.t2 0.3281
R4354 a_1748_53500.n7 a_1748_53500.t0 0.3281
R4355 a_1748_53500.n7 a_1748_53500.t1 0.3281
R4356 a_1748_53500.n6 a_1748_53500.t8 0.3281
R4357 a_1748_53500.n6 a_1748_53500.t11 0.3281
R4358 a_1748_53500.n9 a_1748_53500.n8 0.2005
R4359 a_1748_53500.n9 a_1748_53500.n5 0.2005
R4360 a_1748_53500.n2 a_1748_53500.n1 0.189974
R4361 a_1748_53500.n0 a_1748_53500.t5 0.1643
R4362 a_1748_53500.n0 a_1748_53500.t6 0.1643
R4363 a_1748_53500.n11 a_1748_53500.n1 0.0924286
R4364 a_n4252_53500.n5 a_n4252_53500.n0 15.0138
R4365 a_n4252_53500.n4 a_n4252_53500.n2 15.0138
R4366 a_n4252_53500.n5 a_n4252_53500.n1 14.6138
R4367 a_n4252_53500.n4 a_n4252_53500.n3 14.6138
R4368 a_n4252_53500.n6 a_n4252_53500.n5 6.3955
R4369 a_n4252_53500.n8 a_n4252_53500.t3 6.06762
R4370 a_n4252_53500.t6 a_n4252_53500.n10 5.97267
R4371 a_n4252_53500.n9 a_n4252_53500.n7 5.64507
R4372 a_n4252_53500.n10 a_n4252_53500.n6 4.5005
R4373 a_n4252_53500.n8 a_n4252_53500.n6 2.40435
R4374 a_n4252_53500.n5 a_n4252_53500.n4 0.4005
R4375 a_n4252_53500.n7 a_n4252_53500.t4 0.3281
R4376 a_n4252_53500.n7 a_n4252_53500.t5 0.3281
R4377 a_n4252_53500.n0 a_n4252_53500.t1 0.3281
R4378 a_n4252_53500.n0 a_n4252_53500.t0 0.3281
R4379 a_n4252_53500.n1 a_n4252_53500.t11 0.3281
R4380 a_n4252_53500.n1 a_n4252_53500.t8 0.3281
R4381 a_n4252_53500.n3 a_n4252_53500.t10 0.3281
R4382 a_n4252_53500.n3 a_n4252_53500.t7 0.3281
R4383 a_n4252_53500.n2 a_n4252_53500.t2 0.3281
R4384 a_n4252_53500.n2 a_n4252_53500.t9 0.3281
R4385 a_n4252_53500.n10 a_n4252_53500.n9 0.189974
R4386 a_n4252_53500.n9 a_n4252_53500.n8 0.0921777
R4387 a_n5852_53500.n4 a_n5852_53500.n2 19.2915
R4388 a_n5852_53500.n7 a_n5852_53500.n5 19.2915
R4389 a_n5852_53500.n4 a_n5852_53500.n3 19.1138
R4390 a_n5852_53500.n7 a_n5852_53500.n6 19.1138
R4391 a_n5852_53500.n10 a_n5852_53500.n8 9.3805
R4392 a_n5852_53500.t10 a_n5852_53500.n11 6.0679
R4393 a_n5852_53500.n9 a_n5852_53500.t7 5.97267
R4394 a_n5852_53500.n1 a_n5852_53500.n0 5.64507
R4395 a_n5852_53500.n10 a_n5852_53500.n9 4.68997
R4396 a_n5852_53500.n11 a_n5852_53500.n10 2.251
R4397 a_n5852_53500.n8 a_n5852_53500.n7 0.444944
R4398 a_n5852_53500.n8 a_n5852_53500.n4 0.444944
R4399 a_n5852_53500.n0 a_n5852_53500.t8 0.3281
R4400 a_n5852_53500.n0 a_n5852_53500.t9 0.3281
R4401 a_n5852_53500.n2 a_n5852_53500.t4 0.3281
R4402 a_n5852_53500.n2 a_n5852_53500.t2 0.3281
R4403 a_n5852_53500.n3 a_n5852_53500.t5 0.3281
R4404 a_n5852_53500.n3 a_n5852_53500.t1 0.3281
R4405 a_n5852_53500.n6 a_n5852_53500.t6 0.3281
R4406 a_n5852_53500.n6 a_n5852_53500.t3 0.3281
R4407 a_n5852_53500.n5 a_n5852_53500.t0 0.3281
R4408 a_n5852_53500.n5 a_n5852_53500.t11 0.3281
R4409 a_n5852_53500.n9 a_n5852_53500.n1 0.189974
R4410 a_n5852_53500.n11 a_n5852_53500.n1 0.0919091
R4411 XBANK.XSEL.A_N.n8 XBANK.XSEL.A_N.t4 96.4943
R4412 XBANK.XSEL.A_N.n1 XBANK.XSEL.A_N.t6 74.5242
R4413 XBANK.XSEL.A_N.n2 XBANK.XSEL.A_N.t9 74.5242
R4414 XBANK.XSEL.A_N.n1 XBANK.XSEL.A_N.t7 74.4955
R4415 XBANK.XSEL.A_N.n2 XBANK.XSEL.A_N.t8 74.4955
R4416 XBANK.XSEL.A_N.n4 XBANK.XSEL.A_N 53.0695
R4417 XBANK.XSEL.A_N.n0 XBANK.XSEL.A_N.t5 31.5274
R4418 XBANK.XSEL.A_N.n8 XBANK.XSEL.A_N.t0 31.4224
R4419 XBANK.XSEL.A_N XBANK.XSEL.A_N.n3 19.2531
R4420 XBANK.XSEL.A_N.n8 XBANK.XSEL.A_N.t1 11.0041
R4421 XBANK.XSEL.A_N.n3 XBANK.XSEL.A_N.n1 7.28487
R4422 XBANK.XSEL.A_N.n3 XBANK.XSEL.A_N.n2 7.28487
R4423 XBANK.XSEL.A_N.n5 XBANK.XSEL.A_N.t3 5.69917
R4424 XBANK.XSEL.A_N.n6 XBANK.XSEL.A_N.t2 5.69917
R4425 XBANK.XSEL.A_N.n7 XBANK.XSEL.A_N.n6 4.5005
R4426 XBANK.XSEL.A_N.n5 XBANK.XSEL.A_N.n4 4.5005
R4427 XBANK.XSEL.A_N.n6 XBANK.XSEL.A_N.n5 0.189974
R4428 XBANK.XSEL.A_N XBANK.XSEL.A_N.n7 0.1705
R4429 XBANK.XSEL.A_N XBANK.XSEL.A_N.n8 0.1505
R4430 XBANK.XSEL.A_N.n7 XBANK.XSEL.A_N.n0 0.0805
R4431 XBANK.XSEL.A_N.n4 XBANK.XSEL.A_N.n0 0.0805
R4432 XBANK.XSEL.B_N.n8 XBANK.XSEL.B_N.t4 96.4943
R4433 XBANK.XSEL.B_N.n1 XBANK.XSEL.B_N.t6 74.5242
R4434 XBANK.XSEL.B_N.n2 XBANK.XSEL.B_N.t9 74.5242
R4435 XBANK.XSEL.B_N.n1 XBANK.XSEL.B_N.t7 74.4955
R4436 XBANK.XSEL.B_N.n2 XBANK.XSEL.B_N.t8 74.4955
R4437 XBANK.XSEL.B_N.n4 XBANK.XSEL.B_N 49.6352
R4438 XBANK.XSEL.B_N.n0 XBANK.XSEL.B_N.t5 35.6252
R4439 XBANK.XSEL.B_N.n8 XBANK.XSEL.B_N.t3 31.3566
R4440 XBANK.XSEL.B_N XBANK.XSEL.B_N.n3 19.2531
R4441 XBANK.XSEL.B_N.n8 XBANK.XSEL.B_N.t0 11.0041
R4442 XBANK.XSEL.B_N.n3 XBANK.XSEL.B_N.n1 7.28487
R4443 XBANK.XSEL.B_N.n3 XBANK.XSEL.B_N.n2 7.28487
R4444 XBANK.XSEL.B_N.n5 XBANK.XSEL.B_N.t2 5.69917
R4445 XBANK.XSEL.B_N.n6 XBANK.XSEL.B_N.t1 5.69917
R4446 XBANK.XSEL.B_N.n7 XBANK.XSEL.B_N.n6 4.5005
R4447 XBANK.XSEL.B_N.n5 XBANK.XSEL.B_N.n4 4.5005
R4448 XBANK.XSEL.B_N.n6 XBANK.XSEL.B_N.n5 0.189974
R4449 XBANK.XSEL.B_N XBANK.XSEL.B_N.n7 0.1705
R4450 XBANK.XSEL.B_N XBANK.XSEL.B_N.n8 0.1505
R4451 XBANK.XSEL.B_N.n7 XBANK.XSEL.B_N.n0 0.0805
R4452 XBANK.XSEL.B_N.n4 XBANK.XSEL.B_N.n0 0.0805
R4453 XBANK.XSEL.B_P.n4 XBANK.XSEL.B_P.t4 94.691
R4454 XBANK.XSEL.B_P.n0 XBANK.XSEL.B_P.t6 74.5242
R4455 XBANK.XSEL.B_P.n1 XBANK.XSEL.B_P.t9 74.5242
R4456 XBANK.XSEL.B_P.n0 XBANK.XSEL.B_P.t7 74.4955
R4457 XBANK.XSEL.B_P.n1 XBANK.XSEL.B_P.t8 74.4955
R4458 XBANK.XSEL.B_P.n3 XBANK.XSEL.B_P.t5 35.6252
R4459 XBANK.XSEL.B_P.n4 XBANK.XSEL.B_P.t2 21.9418
R4460 XBANK.XSEL.B_P XBANK.XSEL.B_P.n2 19.2531
R4461 XBANK.XSEL.B_P.n5 XBANK.XSEL.B_P.t3 10.9241
R4462 XBANK.XSEL.B_P.n2 XBANK.XSEL.B_P.n0 7.28487
R4463 XBANK.XSEL.B_P.n2 XBANK.XSEL.B_P.n1 7.28487
R4464 XBANK.XSEL.B_P.n7 XBANK.XSEL.B_P.t1 5.69917
R4465 XBANK.XSEL.B_P.n8 XBANK.XSEL.B_P.t0 5.69917
R4466 XBANK.XSEL.B_P.n5 XBANK.XSEL.B_P.n4 4.80115
R4467 XBANK.XSEL.B_P.n9 XBANK.XSEL.B_P.n8 4.5005
R4468 XBANK.XSEL.B_P.n7 XBANK.XSEL.B_P.n6 4.5005
R4469 XBANK.XSEL.B_P.n6 XBANK.XSEL.B_P.n5 0.3205
R4470 XBANK.XSEL.B_P.n8 XBANK.XSEL.B_P.n7 0.189974
R4471 XBANK.XSEL.B_P.n9 XBANK.XSEL.B_P.n3 0.0805
R4472 XBANK.XSEL.B_P.n6 XBANK.XSEL.B_P.n3 0.0805
R4473 XBANK.XSEL.B_P XBANK.XSEL.B_P.n9 0.0405
R4474 XBANK.XSEL.A_P.n4 XBANK.XSEL.A_P.t4 94.691
R4475 XBANK.XSEL.A_P.n0 XBANK.XSEL.A_P.t6 74.5242
R4476 XBANK.XSEL.A_P.n1 XBANK.XSEL.A_P.t9 74.5242
R4477 XBANK.XSEL.A_P.n0 XBANK.XSEL.A_P.t7 74.4955
R4478 XBANK.XSEL.A_P.n1 XBANK.XSEL.A_P.t8 74.4955
R4479 XBANK.XSEL.A_P.n3 XBANK.XSEL.A_P.t5 31.5274
R4480 XBANK.XSEL.A_P.n4 XBANK.XSEL.A_P.t1 22.0076
R4481 XBANK.XSEL.A_P XBANK.XSEL.A_P.n2 19.2531
R4482 XBANK.XSEL.A_P.n5 XBANK.XSEL.A_P.t0 10.9241
R4483 XBANK.XSEL.A_P.n2 XBANK.XSEL.A_P.n0 7.28487
R4484 XBANK.XSEL.A_P.n2 XBANK.XSEL.A_P.n1 7.28487
R4485 XBANK.XSEL.A_P.n7 XBANK.XSEL.A_P.t3 5.69917
R4486 XBANK.XSEL.A_P.n8 XBANK.XSEL.A_P.t2 5.69917
R4487 XBANK.XSEL.A_P.n5 XBANK.XSEL.A_P.n4 4.80115
R4488 XBANK.XSEL.A_P.n9 XBANK.XSEL.A_P.n8 4.5005
R4489 XBANK.XSEL.A_P.n7 XBANK.XSEL.A_P.n6 4.5005
R4490 XBANK.XSEL.A_P.n6 XBANK.XSEL.A_P.n5 0.3205
R4491 XBANK.XSEL.A_P.n8 XBANK.XSEL.A_P.n7 0.189974
R4492 XBANK.XSEL.A_P.n9 XBANK.XSEL.A_P.n3 0.0805
R4493 XBANK.XSEL.A_P.n6 XBANK.XSEL.A_P.n3 0.0805
R4494 XBANK.XSEL.A_P XBANK.XSEL.A_P.n9 0.0405
R4495 a_n2796_53500.n0 a_n2796_53500.t9 74.5242
R4496 a_n2796_53500.n1 a_n2796_53500.t12 74.5242
R4497 a_n2796_53500.n0 a_n2796_53500.t10 74.4955
R4498 a_n2796_53500.n1 a_n2796_53500.t11 74.4955
R4499 a_n2796_53500.n3 a_n2796_53500.n2 21.8397
R4500 a_n2796_53500.n3 a_n2796_53500.t4 12.772
R4501 a_n2796_53500.n2 a_n2796_53500.n0 7.28371
R4502 a_n2796_53500.n2 a_n2796_53500.n1 7.28371
R4503 a_n2796_53500.t3 a_n2796_53500.n14 6.0676
R4504 a_n2796_53500.n4 a_n2796_53500.t5 6.0676
R4505 a_n2796_53500.n4 a_n2796_53500.t6 6.06436
R4506 a_n2796_53500.n14 a_n2796_53500.t2 6.06436
R4507 a_n2796_53500.n12 a_n2796_53500.t1 5.97267
R4508 a_n2796_53500.n11 a_n2796_53500.t0 5.97267
R4509 a_n2796_53500.n7 a_n2796_53500.t8 5.97267
R4510 a_n2796_53500.n6 a_n2796_53500.t7 5.97267
R4511 a_n2796_53500.n6 a_n2796_53500.n5 4.5005
R4512 a_n2796_53500.n8 a_n2796_53500.n7 4.5005
R4513 a_n2796_53500.n11 a_n2796_53500.n10 4.5005
R4514 a_n2796_53500.n13 a_n2796_53500.n12 4.5005
R4515 a_n2796_53500.n5 a_n2796_53500.n4 2.48391
R4516 a_n2796_53500.n14 a_n2796_53500.n13 2.48391
R4517 a_n2796_53500.n9 a_n2796_53500.n3 0.8055
R4518 a_n2796_53500.n12 a_n2796_53500.n11 0.189974
R4519 a_n2796_53500.n7 a_n2796_53500.n6 0.189974
R4520 a_n2796_53500.n8 a_n2796_53500.n5 0.1605
R4521 a_n2796_53500.n13 a_n2796_53500.n10 0.1605
R4522 a_n2796_53500.n9 a_n2796_53500.n8 0.1205
R4523 a_n2796_53500.n10 a_n2796_53500.n9 0.1205
R4524 a_n5996_53500.n0 a_n5996_53500.t9 74.5242
R4525 a_n5996_53500.n1 a_n5996_53500.t12 74.5242
R4526 a_n5996_53500.n0 a_n5996_53500.t10 74.4955
R4527 a_n5996_53500.n1 a_n5996_53500.t11 74.4955
R4528 a_n5996_53500.n3 a_n5996_53500.n2 29.0226
R4529 a_n5996_53500.n3 a_n5996_53500.t8 12.972
R4530 a_n5996_53500.n2 a_n5996_53500.n0 7.28371
R4531 a_n5996_53500.n2 a_n5996_53500.n1 7.28371
R4532 a_n5996_53500.t3 a_n5996_53500.n14 6.0676
R4533 a_n5996_53500.n4 a_n5996_53500.t4 6.0676
R4534 a_n5996_53500.n4 a_n5996_53500.t5 6.06436
R4535 a_n5996_53500.n14 a_n5996_53500.t2 6.06436
R4536 a_n5996_53500.n12 a_n5996_53500.t1 5.97267
R4537 a_n5996_53500.n11 a_n5996_53500.t0 5.97267
R4538 a_n5996_53500.n7 a_n5996_53500.t7 5.97267
R4539 a_n5996_53500.n6 a_n5996_53500.t6 5.97267
R4540 a_n5996_53500.n6 a_n5996_53500.n5 4.5005
R4541 a_n5996_53500.n8 a_n5996_53500.n7 4.5005
R4542 a_n5996_53500.n11 a_n5996_53500.n10 4.5005
R4543 a_n5996_53500.n13 a_n5996_53500.n12 4.5005
R4544 a_n5996_53500.n5 a_n5996_53500.n4 2.48391
R4545 a_n5996_53500.n14 a_n5996_53500.n13 2.48391
R4546 a_n5996_53500.n9 a_n5996_53500.n3 0.6055
R4547 a_n5996_53500.n12 a_n5996_53500.n11 0.189974
R4548 a_n5996_53500.n7 a_n5996_53500.n6 0.189974
R4549 a_n5996_53500.n8 a_n5996_53500.n5 0.1605
R4550 a_n5996_53500.n13 a_n5996_53500.n10 0.1605
R4551 a_n5996_53500.n9 a_n5996_53500.n8 0.1205
R4552 a_n5996_53500.n10 a_n5996_53500.n9 0.1205
R4553 a_2148_67400.n5 a_2148_67400.n3 10.7042
R4554 a_2148_67400.n5 a_2148_67400.n4 10.7042
R4555 a_2148_67400.t3 a_2148_67400.n7 6.77
R4556 a_2148_67400.n2 a_2148_67400.t0 6.6753
R4557 a_2148_67400.n1 a_2148_67400.n0 6.5388
R4558 a_2148_67400.n6 a_2148_67400.n2 4.63668
R4559 a_2148_67400.n7 a_2148_67400.n6 2.23814
R4560 a_2148_67400.n6 a_2148_67400.n5 0.5055
R4561 a_2148_67400.n2 a_2148_67400.n1 0.189974
R4562 a_2148_67400.n3 a_2148_67400.t5 0.1643
R4563 a_2148_67400.n3 a_2148_67400.t4 0.1643
R4564 a_2148_67400.n4 a_2148_67400.t7 0.1643
R4565 a_2148_67400.n4 a_2148_67400.t6 0.1643
R4566 a_2148_67400.n0 a_2148_67400.t1 0.137
R4567 a_2148_67400.n0 a_2148_67400.t2 0.137
R4568 a_2148_67400.n7 a_2148_67400.n1 0.0924286
R4569 XREST.IN_N.n0 XREST.IN_N.t5 139.689
R4570 XREST.IN_N.n0 XREST.IN_N.t6 139.689
R4571 XREST.IN_N XREST.IN_N.n0 25.9192
R4572 XREST.IN_N.n1 XREST.IN_N 12.5018
R4573 XREST.IN_N.n1 XREST.IN_N.t0 12.3242
R4574 XREST.IN_N.n2 XREST.IN_N.t1 6.0676
R4575 XREST.IN_N.n3 XREST.IN_N.t4 6.06663
R4576 XREST.IN_N.n3 XREST.IN_N.t3 6.0653
R4577 XREST.IN_N.n2 XREST.IN_N.t2 6.06436
R4578 XREST.IN_N.n4 XREST.IN_N.n2 2.46891
R4579 XREST.IN_N.n4 XREST.IN_N.n3 2.22074
R4580 XREST.IN_N XREST.IN_N.n4 0.982318
R4581 XREST.IN_N XREST.IN_N.n1 0.201364
R4582 XREST.IN_P.n0 XREST.IN_P.t5 139.689
R4583 XREST.IN_P.n0 XREST.IN_P.t6 139.689
R4584 XREST.IN_P XREST.IN_P.n0 25.9192
R4585 XREST.IN_P.n1 XREST.IN_P 12.5018
R4586 XREST.IN_P.n1 XREST.IN_P.t4 12.3242
R4587 XREST.IN_P.n3 XREST.IN_P.t3 6.0676
R4588 XREST.IN_P.n2 XREST.IN_P.t0 6.06663
R4589 XREST.IN_P.n2 XREST.IN_P.t1 6.0653
R4590 XREST.IN_P.n3 XREST.IN_P.t2 6.06436
R4591 XREST.IN_P.n4 XREST.IN_P.n3 2.46891
R4592 XREST.IN_P.n4 XREST.IN_P.n2 2.22074
R4593 XREST.IN_P XREST.IN_P.n4 0.982318
R4594 XREST.IN_P XREST.IN_P.n1 0.201364
R4595 a_2148_76800.n5 a_2148_76800.n3 10.7042
R4596 a_2148_76800.n5 a_2148_76800.n4 10.7042
R4597 a_2148_76800.t3 a_2148_76800.n7 6.77
R4598 a_2148_76800.n2 a_2148_76800.t0 6.6753
R4599 a_2148_76800.n1 a_2148_76800.n0 6.5388
R4600 a_2148_76800.n6 a_2148_76800.n2 4.63668
R4601 a_2148_76800.n7 a_2148_76800.n6 2.23814
R4602 a_2148_76800.n6 a_2148_76800.n5 0.5055
R4603 a_2148_76800.n2 a_2148_76800.n1 0.189974
R4604 a_2148_76800.n3 a_2148_76800.t5 0.1643
R4605 a_2148_76800.n3 a_2148_76800.t4 0.1643
R4606 a_2148_76800.n4 a_2148_76800.t6 0.1643
R4607 a_2148_76800.n4 a_2148_76800.t7 0.1643
R4608 a_2148_76800.n0 a_2148_76800.t1 0.137
R4609 a_2148_76800.n0 a_2148_76800.t2 0.137
R4610 a_2148_76800.n7 a_2148_76800.n1 0.0924286
R4611 a_3600_70348.n0 a_3600_70348.t4 139.689
R4612 a_3600_70348.n0 a_3600_70348.t3 139.689
R4613 a_3600_70348.n1 a_3600_70348.n0 37.2961
R4614 a_3600_70348.n1 a_3600_70348.t0 12.392
R4615 a_3600_70348.n2 a_3600_70348.t1 6.0613
R4616 a_3600_70348.t2 a_3600_70348.n2 6.0613
R4617 a_3600_70348.n2 a_3600_70348.n1 2.78832
R4618 a_2000_70348.n0 a_2000_70348.t4 139.689
R4619 a_2000_70348.n0 a_2000_70348.t3 139.689
R4620 a_2000_70348.n1 a_2000_70348.n0 37.2961
R4621 a_2000_70348.n1 a_2000_70348.t2 12.392
R4622 a_2000_70348.n2 a_2000_70348.t0 6.0613
R4623 a_2000_70348.t1 a_2000_70348.n2 6.0613
R4624 a_2000_70348.n2 a_2000_70348.n1 2.78832
R4625 a_14228_86600.n5 a_14228_86600.n3 10.7791
R4626 a_14228_86600.n5 a_14228_86600.n4 10.7791
R4627 a_14228_86600.t5 a_14228_86600.n7 6.55182
R4628 a_14228_86600.n2 a_14228_86600.t2 6.45713
R4629 a_14228_86600.n1 a_14228_86600.n0 6.29333
R4630 a_14228_86600.n6 a_14228_86600.n2 4.63668
R4631 a_14228_86600.n7 a_14228_86600.n6 2.23814
R4632 a_14228_86600.n6 a_14228_86600.n5 0.3305
R4633 a_14228_86600.n3 a_14228_86600.t7 0.20525
R4634 a_14228_86600.n3 a_14228_86600.t6 0.20525
R4635 a_14228_86600.n4 a_14228_86600.t1 0.20525
R4636 a_14228_86600.n4 a_14228_86600.t0 0.20525
R4637 a_14228_86600.n2 a_14228_86600.n1 0.189974
R4638 a_14228_86600.n0 a_14228_86600.t3 0.1643
R4639 a_14228_86600.n0 a_14228_86600.t4 0.1643
R4640 a_14228_86600.n7 a_14228_86600.n1 0.0924286
R4641 a_4628_86600.n3 a_4628_86600.n1 10.7791
R4642 a_4628_86600.n3 a_4628_86600.n2 10.7791
R4643 a_4628_86600.n0 a_4628_86600.t7 6.55182
R4644 a_4628_86600.n5 a_4628_86600.t4 6.45713
R4645 a_4628_86600.n7 a_4628_86600.n6 6.29333
R4646 a_4628_86600.n5 a_4628_86600.n4 4.63668
R4647 a_4628_86600.n4 a_4628_86600.n0 2.23814
R4648 a_4628_86600.n4 a_4628_86600.n3 0.3305
R4649 a_4628_86600.n1 a_4628_86600.t0 0.20525
R4650 a_4628_86600.n1 a_4628_86600.t1 0.20525
R4651 a_4628_86600.n2 a_4628_86600.t2 0.20525
R4652 a_4628_86600.n2 a_4628_86600.t3 0.20525
R4653 a_4628_86600.n6 a_4628_86600.n5 0.189974
R4654 a_4628_86600.n7 a_4628_86600.t5 0.1643
R4655 a_4628_86600.t6 a_4628_86600.n7 0.1643
R4656 a_4628_86600.n6 a_4628_86600.n0 0.0924286
R4657 XREST.OUT_N.n0 XREST.OUT_N.t5 113.618
R4658 XREST.OUT_N.n0 XREST.OUT_N.t6 113.618
R4659 XREST.OUT_N.n1 XREST.OUT_N.t3 113.618
R4660 XREST.OUT_N.n1 XREST.OUT_N.t4 113.618
R4661 XREST.OUT_N.n2 XREST.OUT_N.n1 25.1703
R4662 XREST.OUT_N.n2 XREST.OUT_N.n0 20.9071
R4663 XREST.OUT_N.n4 XREST.OUT_N.t0 12.39
R4664 XREST.OUT_N.n4 XREST.OUT_N 7.8684
R4665 XREST.OUT_N.n5 XREST.OUT_N.t2 6.0613
R4666 XREST.OUT_N.n5 XREST.OUT_N.t1 6.0613
R4667 XREST.OUT_N.n3 XREST.OUT_N.n2 3.15287
R4668 XREST.OUT_N XREST.OUT_N.n5 2.70032
R4669 XREST.OUT_N.n3 XREST.OUT_N 0.118921
R4670 XREST.OUT_N XREST.OUT_N.n4 0.0905
R4671 XREST.OUT_N XREST.OUT_N.n3 0.0794474
R4672 XREST.OUT_P.n0 XREST.OUT_P.t5 113.618
R4673 XREST.OUT_P.n0 XREST.OUT_P.t6 113.618
R4674 XREST.OUT_P.n1 XREST.OUT_P.t3 113.618
R4675 XREST.OUT_P.n1 XREST.OUT_P.t4 113.618
R4676 XREST.OUT_P.n2 XREST.OUT_P.n1 28.3203
R4677 XREST.OUT_P.n2 XREST.OUT_P.n0 25.1624
R4678 XREST.OUT_P.n4 XREST.OUT_P.t0 12.39
R4679 XREST.OUT_P.n4 XREST.OUT_P 12.0234
R4680 XREST.OUT_P.n5 XREST.OUT_P.t2 6.0613
R4681 XREST.OUT_P.n5 XREST.OUT_P.t1 6.0613
R4682 XREST.OUT_P XREST.OUT_P.n5 2.70032
R4683 XREST.OUT_P.n3 XREST.OUT_P.n2 0.927868
R4684 XREST.OUT_P XREST.OUT_P.n4 0.0905
R4685 XREST.OUT_P.n3 XREST.OUT_P 0.0531316
R4686 XREST.OUT_P XREST.OUT_P.n3 0.0355877
R4687 a_14628_89200.n2 a_14628_89200.n0 15.3662
R4688 a_14628_89200.n2 a_14628_89200.n1 14.5662
R4689 a_14628_89200.n3 a_14628_89200.n2 7.70696
R4690 a_14628_89200.n3 a_14628_89200.t5 5.9772
R4691 a_14628_89200.t4 a_14628_89200.n3 5.9772
R4692 a_14628_89200.n0 a_14628_89200.t1 0.2735
R4693 a_14628_89200.n0 a_14628_89200.t0 0.2735
R4694 a_14628_89200.n1 a_14628_89200.t3 0.2735
R4695 a_14628_89200.n1 a_14628_89200.t2 0.2735
R4696 a_13028_89200.n2 a_13028_89200.n0 19.8662
R4697 a_13028_89200.n2 a_13028_89200.n1 19.3329
R4698 a_13028_89200.n3 a_13028_89200.n2 11.5875
R4699 a_13028_89200.n3 a_13028_89200.t5 5.9772
R4700 a_13028_89200.t4 a_13028_89200.n3 5.9772
R4701 a_13028_89200.n1 a_13028_89200.t3 0.2735
R4702 a_13028_89200.n1 a_13028_89200.t2 0.2735
R4703 a_13028_89200.n0 a_13028_89200.t1 0.2735
R4704 a_13028_89200.n0 a_13028_89200.t0 0.2735
R4705 a_5028_89200.n2 a_5028_89200.n0 15.3662
R4706 a_5028_89200.n2 a_5028_89200.n1 14.5662
R4707 a_5028_89200.n3 a_5028_89200.n2 7.70696
R4708 a_5028_89200.n3 a_5028_89200.t1 5.9772
R4709 a_5028_89200.t2 a_5028_89200.n3 5.9772
R4710 a_5028_89200.n0 a_5028_89200.t4 0.2735
R4711 a_5028_89200.n0 a_5028_89200.t0 0.2735
R4712 a_5028_89200.n1 a_5028_89200.t3 0.2735
R4713 a_5028_89200.n1 a_5028_89200.t5 0.2735
R4714 a_3428_89200.n2 a_3428_89200.n0 19.8662
R4715 a_3428_89200.n2 a_3428_89200.n1 19.3329
R4716 a_3428_89200.n3 a_3428_89200.n2 11.5875
R4717 a_3428_89200.n3 a_3428_89200.t5 5.9772
R4718 a_3428_89200.t4 a_3428_89200.n3 5.9772
R4719 a_3428_89200.n1 a_3428_89200.t2 0.2735
R4720 a_3428_89200.n1 a_3428_89200.t3 0.2735
R4721 a_3428_89200.n0 a_3428_89200.t1 0.2735
R4722 a_3428_89200.n0 a_3428_89200.t0 0.2735
R4723 a_4960_89000.n1 a_4960_89000.t9 87.5461
R4724 a_4960_89000.n1 a_4960_89000.t10 87.5461
R4725 a_4960_89000.n8 a_4960_89000.t7 87.5461
R4726 a_4960_89000.n8 a_4960_89000.t8 87.5461
R4727 a_4960_89000.n9 a_4960_89000.n8 36.4819
R4728 a_4960_89000.n2 a_4960_89000.n1 26.3484
R4729 a_4960_89000.n9 a_4960_89000.t4 13.21
R4730 a_4960_89000.n0 a_4960_89000.t1 7.21035
R4731 a_4960_89000.n0 a_4960_89000.t0 7.20745
R4732 a_4960_89000.t3 a_4960_89000.n10 5.96544
R4733 a_4960_89000.n10 a_4960_89000.t2 5.9622
R4734 a_4960_89000.n7 a_4960_89000.n0 5.94824
R4735 a_4960_89000.n5 a_4960_89000.t5 5.87051
R4736 a_4960_89000.n4 a_4960_89000.t6 5.87051
R4737 a_4960_89000.n4 a_4960_89000.n3 4.5005
R4738 a_4960_89000.n6 a_4960_89000.n5 4.5005
R4739 a_4960_89000.n10 a_4960_89000.n9 2.56391
R4740 a_4960_89000.n7 a_4960_89000.n2 0.419
R4741 a_4960_89000.n9 a_4960_89000.n7 0.2415
R4742 a_4960_89000.n5 a_4960_89000.n4 0.189974
R4743 a_4960_89000.n6 a_4960_89000.n3 0.1605
R4744 a_4960_89000.n7 a_4960_89000.n6 0.0795
R4745 a_4960_89000.n3 a_4960_89000.n2 0.0405
R4746 a_3284_89200.n0 a_3284_89200.t7 87.5461
R4747 a_3284_89200.n0 a_3284_89200.t8 87.5461
R4748 a_3284_89200.n7 a_3284_89200.t5 87.5461
R4749 a_3284_89200.n7 a_3284_89200.t6 87.5461
R4750 a_3284_89200.n8 a_3284_89200.n7 36.547
R4751 a_3284_89200.n1 a_3284_89200.n0 35.155
R4752 a_3284_89200.n8 a_3284_89200.t4 13.21
R4753 a_3284_89200.n9 a_3284_89200.t0 5.96544
R4754 a_3284_89200.t1 a_3284_89200.n9 5.9622
R4755 a_3284_89200.n3 a_3284_89200.t3 5.87051
R4756 a_3284_89200.n4 a_3284_89200.t2 5.87051
R4757 a_3284_89200.n5 a_3284_89200.n4 4.5005
R4758 a_3284_89200.n3 a_3284_89200.n2 4.5005
R4759 a_3284_89200.n9 a_3284_89200.n8 2.56391
R4760 a_3284_89200.n6 a_3284_89200.n1 0.419
R4761 a_3284_89200.n8 a_3284_89200.n6 0.2415
R4762 a_3284_89200.n4 a_3284_89200.n3 0.189974
R4763 a_3284_89200.n5 a_3284_89200.n2 0.1605
R4764 a_3284_89200.n6 a_3284_89200.n5 0.0795
R4765 a_3284_89200.n2 a_3284_89200.n1 0.0740593
C0 DIV_BIAS VDD 0.09394f
C1 F_B1 VREFL 0.09381f
C2 VDD XBANK.XFAST.X2.INN 0.27616f
C3 XBANK.XSEL.B_P XBANK.XSEL.B_N 3.35358f
C4 G_A0 G_A0B 0.12533f
C5 F_A2 F_A2B 0.12533f
C6 SEL_BUF SEL_B 0.22922f
C7 a_32500_n24800# a_35500_n24800# 0.24524f
C8 G_A1 VREFH 0.26088f
C9 a_14100_n28902# a_17100_n28902# 0.24827f
C10 a_32500_n24800# a_28800_n29600# 0.20075f
C11 G_B3 VREFL 0.09381f
C12 G_B3B G_B3 0.12533f
C13 REST_BIAS VDD 0.27267f
C14 XBANK.XFAST.X2.INN XBANK.XFAST.XBUF.INN 1.43936f
C15 G_B4B VREFL 0.25739f
C16 F_A3 F_A3B 0.12533f
C17 XBANK.XFAST.X2.INP XBANK.XFAST.X2.INN 0.86002f
C18 F_B1 VREFH 0.26088f
C19 GAIN_KICKP XBANK.XGAIN.XSTART.NODEP 0.05732f
C20 F_A1 VREFL 0.09381f
C21 SEL_B XBANK.XSEL.B_P 0.02033f
C22 a_38500_n24800# XBANK.XGDAC.CTRL_B 0.20694f
C23 DIV_BIAS DIV_RESET 0.24607f
C24 F_B3B VREFL 0.25739f
C25 XREST.OUT_P VDD 0.28476f
C26 G_B3 VREFH 0.26088f
C27 XREST.IN_P REST_BIAS 0.11273f
C28 XBANK.XGAIN.XBUF.INN XBANK.XSEL.B_N 0.18342f
C29 F_B0B F_B0 0.12533f
C30 F_A3 VREFL 0.09381f
C31 VDD XBANK.XGAIN.XBUF.INP 0.76185f
C32 G_B1B VREFL 0.25739f
C33 XBANK.XFDAC.CTRL_A a_n41900_n28902# 0.20694f
C34 XBANK.XFAST.XSTART.NODEP XBANK.XFDAC.CTRL_A 0.27417f
C35 XBANK.XFAST.XSTART.NODEN XBANK.XFDAC.CTRL_B 4.54367f
C36 FAST_KICKN XBANK.XFAST.XSTART.NODEN 0.05905f
C37 SEL_B XBANK.XSEL.B_N 0.14942f
C38 XBANK.XGAIN.XSTART.NODEP XBANK.XGDAC.CTRL_A 0.15638f
C39 XBANK.XGAIN.XSTART.NODEN XBANK.XGDAC.CTRL_B 4.53574f
C40 F_A1 VREFH 0.26088f
C41 G_A3 G_A3B 0.12533f
C42 XBANK.XFDAC.CTRL_A XBANK.XFAST.XBUF.INP 0.54681f
C43 a_n38900_n28902# a_n35900_n28902# 0.24524f
C44 a_14100_n28902# XBANK.XGDAC.CTRL_A 0.20694f
C45 DIV_P DIV_N 1.62269f
C46 F_B4B F_B4 0.12533f
C47 XBANK.XGAIN.X2.INP XBANK.XGAIN.XBUF.INP 1.43949f
C48 G_B0 VREFL 0.09381f
C49 G_A1B VREFL 0.25739f
C50 F_B0B VREFL 0.25739f
C51 XREST.IN_N REST_BIAS 0.11273f
C52 GAIN_KICKP GAIN_KICKN 0.13731f
C53 VDD XBANK.XGAIN.XSTART.NODEN 0.20898f
C54 XREST.OUT_P DIV_RESET 0.61207f
C55 XREST.OUT_N DIV_BIAS 0.71793f
C56 F_A3 VREFH 0.26088f
C57 F_B3 VREFL 0.09381f
C58 XBANK.XFDAC.CTRL_A XBANK.XFAST.XBUF.INN 1.05994f
C59 F_A1 F_A1B 0.12533f
C60 G_A4 G_A4B 0.12533f
C61 XBANK.XGAIN.XBUF.INN XBANK.XGDAC.CTRL_A 0.65519f
C62 XBANK.XFAST.X2.INP XBANK.XFDAC.CTRL_A 0.27417f
C63 XBANK.XFAST.X2.INN XBANK.XFDAC.CTRL_B 0.14401f
C64 a_n41900_n28902# a_n38900_n28902# 0.24827f
C65 DIV_P DIV_BIAS 0.01093f
C66 G_B0 VREFH 0.26088f
C67 XBANK.XGAIN.X2.INN XBANK.XGAIN.XBUF.INN 1.43949f
C68 G_A4B VREFL 0.25739f
C69 G_A2 VREFL 0.09381f
C70 G_B0B G_B0 0.12533f
C71 G_B4B G_B4 0.12533f
C72 F_A3B VREFL 0.25739f
C73 F_B3 VREFH 0.26088f
C74 F_B0 VREFL 0.09381f
C75 XBANK.XGAIN.X2.INN XBANK.XGDAC.CTRL_A 0.13653f
C76 XBANK.XFAST.XSTART.NODEP XBANK.XFAST.XBUF.INP 4.36587f
C77 VDD XBANK.XFAST.XSTART.NODEP 0.55085f
C78 XREST.OUT_P XREST.OUT_N 2.18218f
C79 G_A4 VREFL 0.09381f
C80 SEL_A XBANK.XSEL.A_P 0.14201f
C81 G_A2 VREFH 0.26088f
C82 VDD XBANK.XFAST.XBUF.INP 0.83051f
C83 F_B1B F_B1 0.12533f
C84 XBANK.XGAIN.XBUF.INP XBANK.XSEL.B_P 0.18342f
C85 G_B3B VREFL 0.25739f
C86 XREST.OUT_P DIV_P 0.15102f
C87 VDD XBANK.XSEL.A_N 0.22915f
C88 XBANK.XFAST.XSTART.NODEP XBANK.XFAST.X2.INP 0.18713f
C89 F_B0 VREFH 0.26088f
C90 F_A2 VREFL 0.09381f
C91 XBANK.XFAST.XSTART.NODEN XBANK.XFAST.X2.INN 0.18713f
C92 VDD XBANK.XGAIN.X2.INP 0.48219f
C93 XBANK.XFAST.XBUF.INP XBANK.XFAST.XBUF.INN 0.86002f
C94 VDD XBANK.XFAST.XBUF.INN 0.27616f
C95 SEL_A XBANK.XSEL.B_P 0.1486f
C96 G_A2 G_A2B 0.12533f
C97 XBANK.XGAIN.XSTART.NODEP XBANK.XGAIN.XBUF.INP 4.366f
C98 G_A4 VREFH 0.26088f
C99 G_B2 VREFL 0.09381f
C100 F_B2B VREFL 0.25739f
C101 FAST_KICKP XBANK.XFAST.XSTART.NODEP 0.05732f
C102 XBANK.XFAST.X2.INP XBANK.XFAST.XBUF.INP 1.43936f
C103 VDD XBANK.XFAST.X2.INP 0.55085f
C104 XBANK.XSEL.A_N XBANK.XFAST.XBUF.INN 0.1833f
C105 XBANK.XFDAC.CTRL_A XBANK.XFDAC.CTRL_B 9.62888f
C106 XREST.IN_P VDD 0.91299f
C107 DIV_RESET VDD 0.01587f
C108 VREFH VREFL 0.34519f
C109 G_B0B VREFL 0.25739f
C110 XBANK.XGAIN.XSTART.NODEP XBANK.XGAIN.XSTART.NODEN 0.88357f
C111 SEL_A XBANK.XSEL.B_N 0.0184f
C112 F_A2 VREFH 0.26088f
C113 a_n32900_n28902# a_n35900_n28902# 0.20075f
C114 XBANK.XGAIN.XBUF.INN XBANK.XGAIN.XBUF.INP 0.86001f
C115 G_B2 VREFH 0.26088f
C116 XREST.IN_N VDD 2.09601f
C117 G_A0 VREFL 0.09381f
C118 G_A2B VREFL 0.25739f
C119 F_A0B VREFL 0.25739f
C120 G_B1B G_B1 0.12533f
C121 VDD XBANK.XSEL.A_P 1.93276f
C122 XBANK.XFAST.XBUF.INP XBANK.XSEL.A_P 0.1833f
C123 F_A1B VREFL 0.25739f
C124 VREFL F_A4 0.08914f
C125 XBANK.XSEL.A_N XBANK.XSEL.A_P 3.59127f
C126 XBANK.XGDAC.CTRL_A XBANK.XGAIN.XBUF.INP 0.31276f
C127 F_B2 VREFL 0.09381f
C128 XBANK.XGAIN.XSTART.NODEN XBANK.XGAIN.XBUF.INN 4.366f
C129 SEL_A SEL_B 0.01148f
C130 XREST.OUT_N VDD 1.21238f
C131 GAIN_KICKN XBANK.XGAIN.XSTART.NODEN 0.05905f
C132 VDD XBANK.XSEL.B_P 0.97953f
C133 XBANK.XFAST.XSTART.NODEN XBANK.XFDAC.CTRL_A 0.41927f
C134 XREST.IN_P XREST.IN_N 0.51058f
C135 G_A0 VREFH 0.26088f
C136 G_B4 VREFL 0.08914f
C137 G_A3 VREFL 0.09381f
C138 F_B2B F_B2 0.12533f
C139 XBANK.XGAIN.XSTART.NODEN XBANK.XGDAC.CTRL_A 0.24114f
C140 XBANK.XSEL.A_N XBANK.XSEL.B_P 3.13793f
C141 F_A4B VREFL 0.25739f
C142 VREFH F_A4 0.26088f
C143 DIV_P VDD 0.03367f
C144 XREST.OUT_P DIV_BIAS 0.06565f
C145 F_B2 VREFH 0.26088f
C146 XBANK.XGAIN.XSTART.NODEN XBANK.XGAIN.X2.INN 0.18726f
C147 VDD XBANK.XGAIN.XSTART.NODEP 0.48219f
C148 F_A0 VREFL 0.09381f
C149 G_A1 G_A1B 0.12533f
C150 VDD XBANK.XSEL.B_N 0.30456f
C151 F_B4B VREFL 0.25739f
C152 a_n20500_n24800# a_n17500_n24800# 0.24827f
C153 XBANK.XFDAC.CTRL_B XBANK.XFAST.XBUF.INN 5.77076f
C154 XREST.OUT_N DIV_RESET 0.13985f
C155 XBANK.XSEL.A_N XBANK.XSEL.B_N 0.72385f
C156 G_B4 VREFH 0.26088f
C157 G_A3 VREFH 0.26088f
C158 XBANK.XGAIN.XSTART.NODEP XBANK.XGAIN.X2.INP 0.18726f
C159 XBANK.XGAIN.XBUF.INN XBANK.XGDAC.CTRL_B 5.75172f
C160 XBANK.XFAST.X2.INN XBANK.XFDAC.CTRL_A 0.31147f
C161 G_B2B VREFL 0.25739f
C162 VDD XBANK.XGAIN.XBUF.INN 0.20898f
C163 F_A0 VREFH 0.26088f
C164 DIV_P DIV_RESET 0.17615f
C165 FAST_KICKP FAST_KICKN 0.13731f
C166 XBANK.XGDAC.CTRL_A XBANK.XGDAC.CTRL_B 10.8264f
C167 XBANK.XFAST.XSTART.NODEP XBANK.XFAST.XSTART.NODEN 0.88358f
C168 XBANK.XSEL.A_P XBANK.XSEL.B_P 0.87611f
C169 G_A0B VREFL 0.25739f
C170 G_B1 VREFL 0.09381f
C171 F_B1B VREFL 0.25739f
C172 G_B2B G_B2 0.12533f
C173 a_n17500_n24800# XBANK.XFDAC.CTRL_B 0.20694f
C174 a_n23500_n24800# a_n20500_n24800# 0.24524f
C175 XBANK.XGAIN.X2.INN XBANK.XGDAC.CTRL_B 0.13927f
C176 a_20100_n28902# a_23100_n28902# 0.20075f
C177 SEL_B XBANK.XSEL.A_N 0.14218f
C178 VDD XBANK.XFAST.XSTART.NODEN 0.27616f
C179 F_A0B F_A0 0.12533f
C180 a_n23500_n24800# a_n27200_n29600# 0.20075f
C181 F_A4B F_A4 0.12533f
C182 F_B4 VREFL 0.09275f
C183 DIV_N VDD 0.03367f
C184 VDD XBANK.XGAIN.X2.INN 0.20898f
C185 a_35500_n24800# a_38500_n24800# 0.24827f
C186 XBANK.XGAIN.X2.INP XBANK.XGDAC.CTRL_A 0.15638f
C187 XBANK.XFAST.XSTART.NODEN XBANK.XFAST.XBUF.INN 4.36587f
C188 G_B1 VREFH 0.26088f
C189 F_B3B F_B3 0.12533f
C190 G_A3B VREFL 0.25739f
C191 G_A1 VREFL 0.09381f
C192 a_17100_n28902# a_20100_n28902# 0.24524f
C193 XBANK.XGAIN.X2.INN XBANK.XGAIN.X2.INP 0.86001f
C194 XREST.OUT_N DIV_P 0.56961f
C195 F_A2B VREFL 0.25739f
C196 F_B4 VREFH 0.26088f
C197 G_B4B VSS 2.13457f
C198 G_B3B VSS 2.13453f
C199 G_B2B VSS 2.13453f
C200 G_B1B VSS 2.13453f
C201 G_B0B VSS 2.13453f
C202 G_A0B VSS 2.13453f
C203 G_A1B VSS 2.13453f
C204 G_A2B VSS 2.13453f
C205 G_A3B VSS 2.13453f
C206 G_A4B VSS 2.13457f
C207 G_B4 VSS 3.35924f
C208 G_B3 VSS 3.35416f
C209 G_B2 VSS 3.35416f
C210 G_B1 VSS 3.35416f
C211 G_B0 VSS 3.35416f
C212 G_A0 VSS 3.35416f
C213 G_A1 VSS 3.35416f
C214 G_A2 VSS 3.35416f
C215 G_A3 VSS 3.35416f
C216 G_A4 VSS 3.36508f
C217 F_B4B VSS 2.13457f
C218 F_B3B VSS 2.13453f
C219 F_B2B VSS 2.13453f
C220 F_B1B VSS 2.13453f
C221 F_B0B VSS 2.13453f
C222 F_A0B VSS 2.13453f
C223 F_A1B VSS 2.13453f
C224 F_A2B VSS 2.13453f
C225 F_A3B VSS 2.13453f
C226 F_A4B VSS 2.13457f
C227 VREFH VSS 33.61518f
C228 F_B4 VSS 3.35895f
C229 F_B3 VSS 3.35416f
C230 F_B2 VSS 3.35416f
C231 F_B1 VSS 3.35416f
C232 F_B0 VSS 3.35416f
C233 F_A0 VSS 3.35416f
C234 F_A1 VSS 3.35416f
C235 F_A2 VSS 3.35416f
C236 F_A3 VSS 3.35416f
C237 F_A4 VSS 3.36579f
C238 VREFL VSS 46.81561f
C239 GAIN_KICKN VSS 1.74963f
C240 GAIN_KICKP VSS 1.7158f
C241 FAST_KICKN VSS 1.74963f
C242 FAST_KICKP VSS 1.7158f
C243 SEL_B VSS 5.21771f
C244 SEL_A VSS 4.18664f
C245 SEL_BUF VSS 3.41177f
C246 REST_BIAS VSS 6.21541f
C247 DIV_RESET VSS 3.72071f
C248 DIV_BIAS VSS 7.41339f
C249 DIV_N VSS 7.83695f
C250 DIV_P VSS 12.53262f
C251 VDD VSS 0.17959p
C252 a_38500_n24800# VSS 5.20362f
C253 a_35500_n24800# VSS 5.27319f
C254 a_28800_n29600# VSS 4.18334f
C255 a_32500_n24800# VSS 5.98141f
C256 a_23100_n28902# VSS 4.18334f
C257 a_20100_n28902# VSS 5.98141f
C258 a_17100_n28902# VSS 5.27319f
C259 a_14100_n28902# VSS 5.20362f
C260 a_n17500_n24800# VSS 5.20362f
C261 a_n20500_n24800# VSS 5.27319f
C262 a_n27200_n29600# VSS 4.18334f
C263 a_n23500_n24800# VSS 5.98141f
C264 a_n32900_n28902# VSS 4.18334f
C265 a_n35900_n28902# VSS 5.98141f
C266 a_n38900_n28902# VSS 5.27319f
C267 a_n41900_n28902# VSS 5.20362f
C268 XBANK.XGAIN.XSTART.NODEN VSS 21.7925f
C269 XBANK.XGAIN.XSTART.NODEP VSS 21.56697f
C270 XBANK.XFAST.XSTART.NODEN VSS 21.83153f
C271 XBANK.XFAST.XSTART.NODEP VSS 21.62777f
C272 XBANK.XGAIN.X2.INN VSS 15.03916f
C273 XBANK.XGAIN.X2.INP VSS 15.29174f
C274 XBANK.XFAST.X2.INN VSS 15.08411f
C275 XBANK.XFAST.X2.INP VSS 15.34884f
C276 XBANK.XGAIN.XBUF.INN VSS 28.42048f
C277 XBANK.XGAIN.XBUF.INP VSS 30.14346f
C278 XBANK.XFAST.XBUF.INN VSS 28.26561f
C279 XBANK.XFAST.XBUF.INP VSS 30.12383f
C280 XBANK.XSEL.A_N VSS 24.62635f
C281 XBANK.XSEL.B_N VSS 29.51592f
C282 XBANK.XSEL.B_P VSS 30.01324f
C283 XBANK.XSEL.A_P VSS 30.46792f
C284 XREST.IN_N VSS 8.37029f
C285 XREST.IN_P VSS 8.54864f
C286 XREST.OUT_N VSS 10.33441f
C287 XREST.OUT_P VSS 11.14513f
C288 a_3284_89200.t0 VSS 0.24619f
C289 a_3284_89200.t4 VSS 0.11782f
C290 a_3284_89200.n0 VSS 0.26675f
C291 a_3284_89200.n1 VSS 0.64514f
C292 a_3284_89200.n2 VSS 0.06332f
C293 a_3284_89200.t3 VSS 0.25018f
C294 a_3284_89200.n3 VSS 0.06487f
C295 a_3284_89200.t2 VSS 0.25018f
C296 a_3284_89200.n4 VSS 0.06487f
C297 a_3284_89200.n5 VSS 0.05515f
C298 a_3284_89200.n6 VSS 0.20259f
C299 a_3284_89200.n7 VSS 1.25274f
C300 a_3284_89200.n8 VSS 3.57313f
C301 a_3284_89200.n9 VSS 0.15007f
C302 a_3284_89200.t1 VSS 0.24612f
C303 a_4960_89000.t2 VSS 0.3367f
C304 a_4960_89000.t4 VSS 0.17183f
C305 a_4960_89000.t0 VSS 0.10737f
C306 a_4960_89000.t1 VSS 0.10746f
C307 a_4960_89000.n0 VSS 0.84645f
C308 a_4960_89000.n1 VSS 0.2785f
C309 a_4960_89000.n2 VSS 0.92958f
C310 a_4960_89000.n3 VSS 0.0673f
C311 a_4960_89000.t5 VSS 0.32485f
C312 a_4960_89000.t6 VSS 0.32485f
C313 a_4960_89000.n4 VSS 0.0946f
C314 a_4960_89000.n5 VSS 0.0946f
C315 a_4960_89000.n6 VSS 0.08043f
C316 a_4960_89000.n7 VSS 1.42002f
C317 a_4960_89000.n8 VSS 0.9783f
C318 a_4960_89000.n9 VSS 2.96344f
C319 a_4960_89000.n10 VSS 0.21887f
C320 a_4960_89000.t3 VSS 0.3368f
C321 a_3428_89200.t5 VSS 0.63222f
C322 a_3428_89200.t1 VSS 0.13366f
C323 a_3428_89200.t0 VSS 0.13366f
C324 a_3428_89200.n0 VSS 0.50244f
C325 a_3428_89200.t2 VSS 0.13449f
C326 a_3428_89200.t3 VSS 0.13449f
C327 a_3428_89200.n1 VSS 0.46578f
C328 a_3428_89200.n2 VSS 3.55595f
C329 a_3428_89200.n3 VSS 0.49188f
C330 a_3428_89200.t4 VSS 0.63222f
C331 a_5028_89200.t1 VSS 0.84438f
C332 a_5028_89200.t4 VSS 0.16874f
C333 a_5028_89200.t0 VSS 0.16874f
C334 a_5028_89200.n0 VSS 0.60338f
C335 a_5028_89200.t3 VSS 0.15247f
C336 a_5028_89200.t5 VSS 0.15247f
C337 a_5028_89200.n1 VSS 0.56653f
C338 a_5028_89200.n2 VSS 2.70161f
C339 a_5028_89200.n3 VSS 0.66423f
C340 a_5028_89200.t2 VSS 0.84438f
C341 a_13028_89200.t5 VSS 0.65656f
C342 a_13028_89200.t1 VSS 0.12422f
C343 a_13028_89200.t0 VSS 0.12422f
C344 a_13028_89200.n0 VSS 0.50792f
C345 a_13028_89200.t3 VSS 0.1405f
C346 a_13028_89200.t2 VSS 0.1405f
C347 a_13028_89200.n1 VSS 0.47086f
C348 a_13028_89200.n2 VSS 3.59472f
C349 a_13028_89200.n3 VSS 0.49724f
C350 a_13028_89200.t4 VSS 0.65656f
C351 a_14628_89200.t5 VSS 0.8274f
C352 a_14628_89200.t1 VSS 0.16301f
C353 a_14628_89200.t0 VSS 0.16301f
C354 a_14628_89200.n0 VSS 0.60416f
C355 a_14628_89200.t3 VSS 0.16384f
C356 a_14628_89200.t2 VSS 0.16384f
C357 a_14628_89200.n1 VSS 0.56726f
C358 a_14628_89200.n2 VSS 2.7051f
C359 a_14628_89200.n3 VSS 0.66508f
C360 a_14628_89200.t4 VSS 0.8274f
C361 XREST.OUT_P.t0 VSS 0.10034f
C362 XREST.OUT_P.n0 VSS 0.17146f
C363 XREST.OUT_P.n1 VSS 0.32951f
C364 XREST.OUT_P.n2 VSS 3.02978f
C365 XREST.OUT_P.n3 VSS 0.4202f
C366 XREST.OUT_P.n4 VSS 0.67868f
C367 XREST.OUT_P.t1 VSS 0.41472f
C368 XREST.OUT_P.t2 VSS 0.41472f
C369 XREST.OUT_P.n5 VSS 0.17915f
C370 XREST.OUT_N.t0 VSS 0.13747f
C371 XREST.OUT_N.n0 VSS 0.21376f
C372 XREST.OUT_N.n1 VSS 0.43442f
C373 XREST.OUT_N.n2 VSS 3.117f
C374 XREST.OUT_N.n3 VSS 0.83269f
C375 XREST.OUT_N.n4 VSS 0.58643f
C376 XREST.OUT_N.t1 VSS 0.57613f
C377 XREST.OUT_N.t2 VSS 0.57613f
C378 XREST.OUT_N.n5 VSS 0.24544f
C379 a_4628_86600.t5 VSS 0.14062f
C380 a_4628_86600.t7 VSS 0.58128f
C381 a_4628_86600.n0 VSS 0.11699f
C382 a_4628_86600.t1 VSS 0.15523f
C383 a_4628_86600.t0 VSS 0.15523f
C384 a_4628_86600.n1 VSS 0.37902f
C385 a_4628_86600.t3 VSS 0.13725f
C386 a_4628_86600.t2 VSS 0.13725f
C387 a_4628_86600.n2 VSS 0.37902f
C388 a_4628_86600.n3 VSS 1.16245f
C389 a_4628_86600.n4 VSS 0.35042f
C390 a_4628_86600.t4 VSS 0.57956f
C391 a_4628_86600.n5 VSS 0.11871f
C392 a_4628_86600.n6 VSS 0.13269f
C393 a_4628_86600.n7 VSS 0.4073f
C394 a_4628_86600.t6 VSS 0.14062f
C395 a_14228_86600.t4 VSS 0.13741f
C396 a_14228_86600.t3 VSS 0.13741f
C397 a_14228_86600.n0 VSS 0.39552f
C398 a_14228_86600.n1 VSS 0.12886f
C399 a_14228_86600.t2 VSS 0.56368f
C400 a_14228_86600.n2 VSS 0.11528f
C401 a_14228_86600.t6 VSS 0.13468f
C402 a_14228_86600.t7 VSS 0.13468f
C403 a_14228_86600.n3 VSS 0.36807f
C404 a_14228_86600.t0 VSS 0.15266f
C405 a_14228_86600.t1 VSS 0.15266f
C406 a_14228_86600.n4 VSS 0.36807f
C407 a_14228_86600.n5 VSS 1.12884f
C408 a_14228_86600.n6 VSS 0.34029f
C409 a_14228_86600.n7 VSS 0.11361f
C410 a_14228_86600.t5 VSS 0.56535f
C411 a_2000_70348.t0 VSS 0.44299f
C412 a_2000_70348.t2 VSS 0.10978f
C413 a_2000_70348.n0 VSS 0.61783f
C414 a_2000_70348.n1 VSS 1.88879f
C415 a_2000_70348.n2 VSS 0.20625f
C416 a_2000_70348.t1 VSS 0.44299f
C417 a_3600_70348.t1 VSS 0.64146f
C418 a_3600_70348.t0 VSS 0.1637f
C419 a_3600_70348.n0 VSS 0.92133f
C420 a_3600_70348.n1 VSS 2.81665f
C421 a_3600_70348.n2 VSS 0.30757f
C422 a_3600_70348.t2 VSS 0.64146f
C423 a_2148_76800.t2 VSS 0.18756f
C424 a_2148_76800.t1 VSS 0.18756f
C425 a_2148_76800.n0 VSS 0.50022f
C426 a_2148_76800.n1 VSS 0.14277f
C427 a_2148_76800.t0 VSS 0.72981f
C428 a_2148_76800.n2 VSS 0.12789f
C429 a_2148_76800.t4 VSS 0.21192f
C430 a_2148_76800.t5 VSS 0.21192f
C431 a_2148_76800.n3 VSS 0.46537f
C432 a_2148_76800.t7 VSS 0.17976f
C433 a_2148_76800.t6 VSS 0.17976f
C434 a_2148_76800.n4 VSS 0.46537f
C435 a_2148_76800.n5 VSS 0.97468f
C436 a_2148_76800.n6 VSS 0.43058f
C437 a_2148_76800.n7 VSS 0.1261f
C438 a_2148_76800.t3 VSS 0.7316f
C439 XREST.IN_P.t4 VSS 0.10202f
C440 XREST.IN_P.n0 VSS 0.20415f
C441 XREST.IN_P.n1 VSS 1.40882f
C442 XREST.IN_P.t1 VSS 0.21568f
C443 XREST.IN_P.t0 VSS 0.21572f
C444 XREST.IN_P.n2 VSS 0.13635f
C445 XREST.IN_P.t3 VSS 0.21575f
C446 XREST.IN_P.t2 VSS 0.21567f
C447 XREST.IN_P.n3 VSS 0.15175f
C448 XREST.IN_P.n4 VSS 0.63527f
C449 XREST.IN_N.t0 VSS 0.12011f
C450 XREST.IN_N.n0 VSS 0.24035f
C451 XREST.IN_N.n1 VSS 1.65866f
C452 XREST.IN_N.t1 VSS 0.25057f
C453 XREST.IN_N.t2 VSS 0.25047f
C454 XREST.IN_N.n2 VSS 0.17866f
C455 XREST.IN_N.t3 VSS 0.25049f
C456 XREST.IN_N.t4 VSS 0.25053f
C457 XREST.IN_N.n3 VSS 0.16053f
C458 XREST.IN_N.n4 VSS 0.74793f
C459 a_2148_67400.t2 VSS 0.19963f
C460 a_2148_67400.t1 VSS 0.19963f
C461 a_2148_67400.n0 VSS 0.54426f
C462 a_2148_67400.n1 VSS 0.15534f
C463 a_2148_67400.t0 VSS 0.78958f
C464 a_2148_67400.n2 VSS 0.13915f
C465 a_2148_67400.t4 VSS 0.19614f
C466 a_2148_67400.t5 VSS 0.19614f
C467 a_2148_67400.n3 VSS 0.50635f
C468 a_2148_67400.t6 VSS 0.18533f
C469 a_2148_67400.t7 VSS 0.18533f
C470 a_2148_67400.n4 VSS 0.50635f
C471 a_2148_67400.n5 VSS 1.06049f
C472 a_2148_67400.n6 VSS 0.46849f
C473 a_2148_67400.n7 VSS 0.1372f
C474 a_2148_67400.t3 VSS 0.79153f
C475 a_n5996_53500.t2 VSS 0.23065f
C476 a_n5996_53500.t8 VSS 0.13641f
C477 a_n5996_53500.n0 VSS 0.08288f
C478 a_n5996_53500.n1 VSS 0.08288f
C479 a_n5996_53500.n2 VSS 1.0083f
C480 a_n5996_53500.n3 VSS 2.13373f
C481 a_n5996_53500.t4 VSS 0.22857f
C482 a_n5996_53500.t5 VSS 0.22848f
C483 a_n5996_53500.n4 VSS 0.18172f
C484 a_n5996_53500.n5 VSS 0.28507f
C485 a_n5996_53500.t7 VSS 0.22724f
C486 a_n5996_53500.t6 VSS 0.22724f
C487 a_n5996_53500.n6 VSS 0.08196f
C488 a_n5996_53500.n7 VSS 0.08196f
C489 a_n5996_53500.n8 VSS 0.08223f
C490 a_n5996_53500.n9 VSS 0.24815f
C491 a_n5996_53500.n10 VSS 0.08223f
C492 a_n5996_53500.t1 VSS 0.22941f
C493 a_n5996_53500.t0 VSS 0.22941f
C494 a_n5996_53500.n11 VSS 0.08196f
C495 a_n5996_53500.n12 VSS 0.08196f
C496 a_n5996_53500.n13 VSS 0.28507f
C497 a_n5996_53500.n14 VSS 0.18172f
C498 a_n5996_53500.t3 VSS 0.23074f
C499 a_n2796_53500.t2 VSS 0.24973f
C500 a_n2796_53500.t4 VSS 0.14037f
C501 a_n2796_53500.n0 VSS 0.09015f
C502 a_n2796_53500.n1 VSS 0.09015f
C503 a_n2796_53500.n2 VSS 0.85875f
C504 a_n2796_53500.n3 VSS 2.09736f
C505 a_n2796_53500.t5 VSS 0.24367f
C506 a_n2796_53500.t6 VSS 0.24358f
C507 a_n2796_53500.n4 VSS 0.19766f
C508 a_n2796_53500.n5 VSS 0.31008f
C509 a_n2796_53500.t8 VSS 0.24223f
C510 a_n2796_53500.t7 VSS 0.24223f
C511 a_n2796_53500.n6 VSS 0.08915f
C512 a_n2796_53500.n7 VSS 0.08915f
C513 a_n2796_53500.n8 VSS 0.08944f
C514 a_n2796_53500.n9 VSS 0.33381f
C515 a_n2796_53500.n10 VSS 0.08944f
C516 a_n2796_53500.t1 VSS 0.24838f
C517 a_n2796_53500.t0 VSS 0.24839f
C518 a_n2796_53500.n11 VSS 0.08915f
C519 a_n2796_53500.n12 VSS 0.08915f
C520 a_n2796_53500.n13 VSS 0.31008f
C521 a_n2796_53500.n14 VSS 0.19766f
C522 a_n2796_53500.t3 VSS 0.24982f
C523 XBANK.XSEL.A_P.n0 VSS 0.03856f
C524 XBANK.XSEL.A_P.n1 VSS 0.03856f
C525 XBANK.XSEL.A_P.n2 VSS 0.16093f
C526 XBANK.XSEL.A_P.n3 VSS 0.21058f
C527 XBANK.XSEL.A_P.t0 VSS 0.14952f
C528 XBANK.XSEL.A_P.t1 VSS 0.08396f
C529 XBANK.XSEL.A_P.n4 VSS 1.19988f
C530 XBANK.XSEL.A_P.n5 VSS 0.56064f
C531 XBANK.XSEL.A_P.n6 VSS 0.05464f
C532 XBANK.XSEL.A_P.t3 VSS 0.12894f
C533 XBANK.XSEL.A_P.n7 VSS 0.04019f
C534 XBANK.XSEL.A_P.t2 VSS 0.12894f
C535 XBANK.XSEL.A_P.n8 VSS 0.04019f
C536 XBANK.XSEL.A_P.n9 VSS 0.01639f
C537 XBANK.XSEL.B_P.n0 VSS 0.04324f
C538 XBANK.XSEL.B_P.n1 VSS 0.04324f
C539 XBANK.XSEL.B_P.n2 VSS 0.18046f
C540 XBANK.XSEL.B_P.n3 VSS 0.24255f
C541 XBANK.XSEL.B_P.t3 VSS 0.14909f
C542 XBANK.XSEL.B_P.t2 VSS 0.09287f
C543 XBANK.XSEL.B_P.n4 VSS 1.31448f
C544 XBANK.XSEL.B_P.n5 VSS 0.6287f
C545 XBANK.XSEL.B_P.n6 VSS 0.06128f
C546 XBANK.XSEL.B_P.t1 VSS 0.14186f
C547 XBANK.XSEL.B_P.n7 VSS 0.04507f
C548 XBANK.XSEL.B_P.t0 VSS 0.14186f
C549 XBANK.XSEL.B_P.n8 VSS 0.04507f
C550 XBANK.XSEL.B_P.n9 VSS 0.01838f
C551 XBANK.XSEL.B_N.n0 VSS 0.17539f
C552 XBANK.XSEL.B_N.n1 VSS 0.03127f
C553 XBANK.XSEL.B_N.n2 VSS 0.03127f
C554 XBANK.XSEL.B_N.n3 VSS 0.13049f
C555 XBANK.XSEL.B_N.n4 VSS 2.60984f
C556 XBANK.XSEL.B_N.t2 VSS 0.11784f
C557 XBANK.XSEL.B_N.n5 VSS 0.03259f
C558 XBANK.XSEL.B_N.t1 VSS 0.11784f
C559 XBANK.XSEL.B_N.n6 VSS 0.03259f
C560 XBANK.XSEL.B_N.n7 VSS 0.02769f
C561 XBANK.XSEL.B_N.t0 VSS 0.11235f
C562 XBANK.XSEL.B_N.t3 VSS 0.20438f
C563 XBANK.XSEL.B_N.n8 VSS 1.09347f
C564 XBANK.XSEL.A_N.n0 VSS 0.24325f
C565 XBANK.XSEL.A_N.n1 VSS 0.04454f
C566 XBANK.XSEL.A_N.n2 VSS 0.04454f
C567 XBANK.XSEL.A_N.n3 VSS 0.18589f
C568 XBANK.XSEL.A_N.n4 VSS 3.44521f
C569 XBANK.XSEL.A_N.t3 VSS 0.15611f
C570 XBANK.XSEL.A_N.n5 VSS 0.04643f
C571 XBANK.XSEL.A_N.t2 VSS 0.15611f
C572 XBANK.XSEL.A_N.n6 VSS 0.04643f
C573 XBANK.XSEL.A_N.n7 VSS 0.03945f
C574 XBANK.XSEL.A_N.t1 VSS 0.14581f
C575 XBANK.XSEL.A_N.t0 VSS 0.30165f
C576 XBANK.XSEL.A_N.n8 VSS 1.5805f
C577 a_n5852_53500.t9 VSS 0.08283f
C578 a_n5852_53500.t8 VSS 0.08283f
C579 a_n5852_53500.n0 VSS 0.26015f
C580 a_n5852_53500.n1 VSS 0.15107f
C581 a_n5852_53500.t2 VSS 0.08947f
C582 a_n5852_53500.t4 VSS 0.08947f
C583 a_n5852_53500.n2 VSS 0.38418f
C584 a_n5852_53500.t1 VSS 0.08947f
C585 a_n5852_53500.t5 VSS 0.08947f
C586 a_n5852_53500.n3 VSS 0.3804f
C587 a_n5852_53500.n4 VSS 1.17769f
C588 a_n5852_53500.t11 VSS 0.08669f
C589 a_n5852_53500.t0 VSS 0.0867f
C590 a_n5852_53500.n5 VSS 0.38418f
C591 a_n5852_53500.t3 VSS 0.0867f
C592 a_n5852_53500.t6 VSS 0.08669f
C593 a_n5852_53500.n6 VSS 0.3804f
C594 a_n5852_53500.n7 VSS 1.17769f
C595 a_n5852_53500.n8 VSS 1.81005f
C596 a_n5852_53500.t7 VSS 0.35421f
C597 a_n5852_53500.n9 VSS 0.13683f
C598 a_n5852_53500.n10 VSS 0.36058f
C599 a_n5852_53500.n11 VSS 0.13468f
C600 a_n5852_53500.t10 VSS 0.35636f
C601 a_n4252_53500.t0 VSS 0.08488f
C602 a_n4252_53500.t1 VSS 0.08487f
C603 a_n4252_53500.n0 VSS 0.3664f
C604 a_n4252_53500.t8 VSS 0.08487f
C605 a_n4252_53500.t11 VSS 0.08488f
C606 a_n4252_53500.n1 VSS 0.35603f
C607 a_n4252_53500.t9 VSS 0.09042f
C608 a_n4252_53500.t2 VSS 0.09043f
C609 a_n4252_53500.n2 VSS 0.3664f
C610 a_n4252_53500.t7 VSS 0.09043f
C611 a_n4252_53500.t10 VSS 0.09042f
C612 a_n4252_53500.n3 VSS 0.35603f
C613 a_n4252_53500.n4 VSS 0.84628f
C614 a_n4252_53500.n5 VSS 2.41446f
C615 a_n4252_53500.n6 VSS 0.66754f
C616 a_n4252_53500.t5 VSS 0.08058f
C617 a_n4252_53500.t4 VSS 0.08058f
C618 a_n4252_53500.n7 VSS 0.26603f
C619 a_n4252_53500.t3 VSS 0.36014f
C620 a_n4252_53500.n8 VSS 0.15483f
C621 a_n4252_53500.n9 VSS 0.15449f
C622 a_n4252_53500.n10 VSS 0.136f
C623 a_n4252_53500.t6 VSS 0.35796f
C624 a_1748_53500.t6 VSS 0.13915f
C625 a_1748_53500.t5 VSS 0.13915f
C626 a_1748_53500.n0 VSS 0.41902f
C627 a_1748_53500.n1 VSS 0.13651f
C628 a_1748_53500.t4 VSS 0.59065f
C629 a_1748_53500.n2 VSS 0.12213f
C630 a_1748_53500.t9 VSS 0.0988f
C631 a_1748_53500.t10 VSS 0.09879f
C632 a_1748_53500.n3 VSS 0.25721f
C633 a_1748_53500.t2 VSS 0.09879f
C634 a_1748_53500.t3 VSS 0.0988f
C635 a_1748_53500.n4 VSS 0.24616f
C636 a_1748_53500.n5 VSS 0.55535f
C637 a_1748_53500.t11 VSS 0.09542f
C638 a_1748_53500.t8 VSS 0.09543f
C639 a_1748_53500.n6 VSS 0.25721f
C640 a_1748_53500.t1 VSS 0.09543f
C641 a_1748_53500.t0 VSS 0.09542f
C642 a_1748_53500.n7 VSS 0.24616f
C643 a_1748_53500.n8 VSS 0.55535f
C644 a_1748_53500.n9 VSS 0.39669f
C645 a_1748_53500.n10 VSS 0.59694f
C646 a_1748_53500.n11 VSS 0.12036f
C647 a_1748_53500.t7 VSS 0.59242f
C648 XBANK.XFAST.XBUF.INP.n0 VSS 0.11704f
C649 XBANK.XFAST.XBUF.INP.n1 VSS 0.11704f
C650 XBANK.XFAST.XBUF.INP.n2 VSS 3.82357f
C651 XBANK.XFAST.XBUF.INP.n3 VSS 0.28291f
C652 XBANK.XFAST.XBUF.INP.t3 VSS 0.18034f
C653 XBANK.XFAST.XBUF.INP.t2 VSS 0.09263f
C654 XBANK.XFAST.XBUF.INP.n4 VSS 1.3238f
C655 XBANK.XFAST.XBUF.INP.n5 VSS 0.61855f
C656 XBANK.XFAST.XBUF.INP.n6 VSS 0.06029f
C657 XBANK.XFAST.XBUF.INP.t1 VSS 0.14051f
C658 XBANK.XFAST.XBUF.INP.n7 VSS 0.04434f
C659 XBANK.XFAST.XBUF.INP.t0 VSS 0.14051f
C660 XBANK.XFAST.XBUF.INP.n8 VSS 0.04434f
C661 XBANK.XFAST.XBUF.INP.n9 VSS 0.01809f
C662 a_n31052_37900.t5 VSS 0.10859f
C663 a_n31052_37900.t7 VSS 0.6462f
C664 a_n31052_37900.n0 VSS 0.09288f
C665 a_n31052_37900.n1 VSS 0.06772f
C666 a_n31052_37900.n2 VSS 0.06772f
C667 a_n31052_37900.t3 VSS 0.06613f
C668 a_n31052_37900.t2 VSS 0.06613f
C669 a_n31052_37900.n3 VSS 0.25163f
C670 a_n31052_37900.t0 VSS 0.05591f
C671 a_n31052_37900.t1 VSS 0.05591f
C672 a_n31052_37900.n4 VSS 0.22084f
C673 a_n31052_37900.n5 VSS 1.78065f
C674 a_n31052_37900.n6 VSS 0.05098f
C675 a_n31052_37900.n7 VSS 0.04981f
C676 a_n31052_37900.n8 VSS 0.254f
C677 a_n31052_37900.n9 VSS 0.05086f
C678 a_n31052_37900.n10 VSS 0.04994f
C679 a_n31052_37900.t4 VSS 0.6462f
C680 a_n31052_37900.n11 VSS 0.09288f
C681 a_n31052_37900.n12 VSS 0.10043f
C682 a_n31052_37900.n13 VSS 0.50607f
C683 a_n31052_37900.t6 VSS 0.10859f
C684 XBANK.XFAST.XBUF.INN.n0 VSS 0.17771f
C685 XBANK.XFAST.XBUF.INN.n1 VSS 0.17771f
C686 XBANK.XFAST.XBUF.INN.n2 VSS 5.80559f
C687 XBANK.XFAST.XBUF.INN.n3 VSS 0.46554f
C688 XBANK.XFAST.XBUF.INN.t3 VSS 0.20339f
C689 XBANK.XFAST.XBUF.INN.n4 VSS 0.06797f
C690 XBANK.XFAST.XBUF.INN.t2 VSS 0.20339f
C691 XBANK.XFAST.XBUF.INN.n5 VSS 0.06733f
C692 XBANK.XFAST.XBUF.INN.n6 VSS 0.05721f
C693 XBANK.XFAST.XBUF.INN.t1 VSS 0.20318f
C694 XBANK.XFAST.XBUF.INN.t0 VSS 0.43746f
C695 XBANK.XFAST.XBUF.INN.n7 VSS 2.29208f
C696 a_n28972_38000.t1 VSS 0.25282f
C697 a_n28972_38000.t0 VSS 0.26877f
C698 a_n28972_38000.t3 VSS 0.22652f
C699 a_n28972_38000.n0 VSS 1.11704f
C700 a_n28972_38000.n1 VSS 0.30058f
C701 a_n28972_38000.t2 VSS 0.25282f
C702 XBANK.XGAIN.XBUF.INP.n0 VSS 0.11502f
C703 XBANK.XGAIN.XBUF.INP.n1 VSS 0.11502f
C704 XBANK.XGAIN.XBUF.INP.n2 VSS 3.75744f
C705 XBANK.XGAIN.XBUF.INP.n3 VSS 0.28421f
C706 XBANK.XGAIN.XBUF.INP.t1 VSS 0.1769f
C707 XBANK.XGAIN.XBUF.INP.t0 VSS 0.08979f
C708 XBANK.XGAIN.XBUF.INP.n4 VSS 1.27088f
C709 XBANK.XGAIN.XBUF.INP.n5 VSS 0.60785f
C710 XBANK.XGAIN.XBUF.INP.n6 VSS 0.05925f
C711 XBANK.XGAIN.XBUF.INP.t3 VSS 0.13804f
C712 XBANK.XGAIN.XBUF.INP.n7 VSS 0.04358f
C713 XBANK.XGAIN.XBUF.INP.t2 VSS 0.13804f
C714 XBANK.XGAIN.XBUF.INP.n8 VSS 0.04358f
C715 XBANK.XGAIN.XBUF.INP.n9 VSS 0.01777f
C716 a_24948_37900.n0 VSS 0.05586f
C717 a_24948_37900.t2 VSS 0.07932f
C718 a_24948_37900.t1 VSS 0.07932f
C719 a_24948_37900.n1 VSS 0.36734f
C720 a_24948_37900.t0 VSS 0.46554f
C721 a_24948_37900.n2 VSS 0.0895f
C722 a_24948_37900.n3 VSS 0.07419f
C723 a_24948_37900.t5 VSS 0.06892f
C724 a_24948_37900.t6 VSS 0.06892f
C725 a_24948_37900.n4 VSS 0.2757f
C726 a_24948_37900.t7 VSS 0.05903f
C727 a_24948_37900.t4 VSS 0.05903f
C728 a_24948_37900.n5 VSS 0.24196f
C729 a_24948_37900.n6 VSS 2.00892f
C730 a_24948_37900.n7 VSS 0.05458f
C731 a_24948_37900.n8 VSS 0.33626f
C732 a_24948_37900.n9 VSS 0.05572f
C733 a_24948_37900.n10 VSS 0.05472f
C734 a_24948_37900.n11 VSS 0.07419f
C735 a_24948_37900.n12 VSS 0.09735f
C736 a_24948_37900.n13 VSS 0.0895f
C737 a_24948_37900.t3 VSS 0.46554f
C738 XBANK.XGAIN.XBUF.INN.n0 VSS 0.17375f
C739 XBANK.XGAIN.XBUF.INN.n1 VSS 0.17375f
C740 XBANK.XGAIN.XBUF.INN.n2 VSS 5.67609f
C741 XBANK.XGAIN.XBUF.INN.n3 VSS 0.46451f
C742 XBANK.XGAIN.XBUF.INN.t1 VSS 0.19872f
C743 XBANK.XGAIN.XBUF.INN.n4 VSS 0.06645f
C744 XBANK.XGAIN.XBUF.INN.t0 VSS 0.19872f
C745 XBANK.XGAIN.XBUF.INN.n5 VSS 0.06583f
C746 XBANK.XGAIN.XBUF.INN.n6 VSS 0.05594f
C747 XBANK.XGAIN.XBUF.INN.t3 VSS 0.19878f
C748 XBANK.XGAIN.XBUF.INN.t2 VSS 0.41282f
C749 XBANK.XGAIN.XBUF.INN.n7 VSS 2.20861f
C750 a_27028_38000.t3 VSS 0.16978f
C751 a_27028_38000.t0 VSS 0.26879f
C752 a_27028_38000.t1 VSS 0.24136f
C753 a_27028_38000.n0 VSS 1.21648f
C754 a_27028_38000.n1 VSS 0.32499f
C755 a_27028_38000.t2 VSS 0.16978f
C756 XBANK.XFAST.X2.INP.n0 VSS 0.11873f
C757 XBANK.XFAST.X2.INP.n1 VSS 1.08454f
C758 XBANK.XFAST.X2.INP.t2 VSS 0.16156f
C759 XBANK.XFAST.X2.INP.t3 VSS 0.09397f
C760 XBANK.XFAST.X2.INP.n2 VSS 1.34293f
C761 XBANK.XFAST.X2.INP.n3 VSS 0.62748f
C762 XBANK.XFAST.X2.INP.n4 VSS 0.06116f
C763 XBANK.XFAST.X2.INP.t1 VSS 0.14409f
C764 XBANK.XFAST.X2.INP.n5 VSS 0.04498f
C765 XBANK.XFAST.X2.INP.t0 VSS 0.14409f
C766 XBANK.XFAST.X2.INP.n6 VSS 0.04498f
C767 XBANK.XFAST.X2.INP.n7 VSS 0.01835f
C768 a_n31052_25100.t5 VSS 0.10956f
C769 a_n31052_25100.t7 VSS 0.652f
C770 a_n31052_25100.n0 VSS 0.09371f
C771 a_n31052_25100.n1 VSS 0.06832f
C772 a_n31052_25100.n2 VSS 0.06832f
C773 a_n31052_25100.t1 VSS 0.05692f
C774 a_n31052_25100.t0 VSS 0.05692f
C775 a_n31052_25100.n3 VSS 0.25389f
C776 a_n31052_25100.t2 VSS 0.05652f
C777 a_n31052_25100.t3 VSS 0.05652f
C778 a_n31052_25100.n4 VSS 0.22282f
C779 a_n31052_25100.n5 VSS 1.79664f
C780 a_n31052_25100.n6 VSS 0.05144f
C781 a_n31052_25100.n7 VSS 0.05026f
C782 a_n31052_25100.n8 VSS 0.25628f
C783 a_n31052_25100.n9 VSS 0.05131f
C784 a_n31052_25100.n10 VSS 0.05039f
C785 a_n31052_25100.t4 VSS 0.652f
C786 a_n31052_25100.n11 VSS 0.09371f
C787 a_n31052_25100.n12 VSS 0.10133f
C788 a_n31052_25100.n13 VSS 0.51061f
C789 a_n31052_25100.t6 VSS 0.10956f
C790 XBANK.XFAST.X2.INN.n0 VSS 0.12113f
C791 XBANK.XFAST.X2.INN.n1 VSS 1.13097f
C792 XBANK.XFAST.X2.INN.t3 VSS 0.15792f
C793 XBANK.XFAST.X2.INN.n2 VSS 0.04633f
C794 XBANK.XFAST.X2.INN.t2 VSS 0.15792f
C795 XBANK.XFAST.X2.INN.n3 VSS 0.04589f
C796 XBANK.XFAST.X2.INN.n4 VSS 0.039f
C797 XBANK.XFAST.X2.INN.t1 VSS 0.14724f
C798 XBANK.XFAST.X2.INN.t0 VSS 0.29818f
C799 XBANK.XFAST.X2.INN.n5 VSS 1.56232f
C800 a_n28972_25200.t0 VSS 0.25282f
C801 a_n28972_25200.t3 VSS 0.28871f
C802 a_n28972_25200.t2 VSS 0.22898f
C803 a_n28972_25200.n0 VSS 1.11704f
C804 a_n28972_25200.n1 VSS 0.30058f
C805 a_n28972_25200.t1 VSS 14.25412f
C806 XBANK.XGAIN.X2.INP.n0 VSS 0.11646f
C807 XBANK.XGAIN.X2.INP.n1 VSS 1.07009f
C808 XBANK.XGAIN.X2.INP.t0 VSS 0.15805f
C809 XBANK.XGAIN.X2.INP.t3 VSS 0.09092f
C810 XBANK.XGAIN.X2.INP.n2 VSS 1.28688f
C811 XBANK.XGAIN.X2.INP.n3 VSS 0.6155f
C812 XBANK.XGAIN.X2.INP.n4 VSS 0.05999f
C813 XBANK.XGAIN.X2.INP.t2 VSS 0.14149f
C814 XBANK.XGAIN.X2.INP.n5 VSS 0.04412f
C815 XBANK.XGAIN.X2.INP.t1 VSS 0.14149f
C816 XBANK.XGAIN.X2.INP.n6 VSS 0.04412f
C817 XBANK.XGAIN.X2.INP.n7 VSS 0.018f
C818 a_24948_25100.n0 VSS 0.05638f
C819 a_24948_25100.t4 VSS 25.5359f
C820 a_24948_25100.t3 VSS 0.08005f
C821 a_24948_25100.n1 VSS 0.37074f
C822 a_24948_25100.t2 VSS 0.46985f
C823 a_24948_25100.n2 VSS 0.09033f
C824 a_24948_25100.n3 VSS 0.07488f
C825 a_24948_25100.t1 VSS 0.05984f
C826 a_24948_25100.t0 VSS 0.05984f
C827 a_24948_25100.n4 VSS 0.27826f
C828 a_24948_25100.t7 VSS 0.05964f
C829 a_24948_25100.t6 VSS 0.05964f
C830 a_24948_25100.n5 VSS 0.2442f
C831 a_24948_25100.n6 VSS 2.02754f
C832 a_24948_25100.n7 VSS 0.05509f
C833 a_24948_25100.n8 VSS 0.33937f
C834 a_24948_25100.n9 VSS 0.05624f
C835 a_24948_25100.n10 VSS 0.05522f
C836 a_24948_25100.n11 VSS 0.07488f
C837 a_24948_25100.n12 VSS 0.09825f
C838 a_24948_25100.n13 VSS 0.09033f
C839 a_24948_25100.t5 VSS 0.46985f
C840 XBANK.XGAIN.X2.INN.n0 VSS 0.11765f
C841 XBANK.XGAIN.X2.INN.n1 VSS 1.10485f
C842 XBANK.XGAIN.X2.INN.t1 VSS 0.15402f
C843 XBANK.XGAIN.X2.INN.n2 VSS 0.045f
C844 XBANK.XGAIN.X2.INN.t0 VSS 0.15402f
C845 XBANK.XGAIN.X2.INN.n3 VSS 0.04458f
C846 XBANK.XGAIN.X2.INN.n4 VSS 0.03788f
C847 XBANK.XGAIN.X2.INN.t3 VSS 0.14327f
C848 XBANK.XGAIN.X2.INN.t2 VSS 0.27954f
C849 XBANK.XGAIN.X2.INN.n5 VSS 1.49559f
C850 a_27028_25200.t1 VSS 0.16978f
C851 a_27028_25200.t0 VSS 0.30051f
C852 a_27028_25200.t3 VSS 0.24047f
C853 a_27028_25200.n0 VSS 1.21648f
C854 a_27028_25200.n1 VSS 0.32499f
C855 a_27028_25200.t2 VSS 0.16978f
C856 XBANK.XFAST.XSTART.NODEP.t3 VSS 0.06939f
C857 XBANK.XFAST.XSTART.NODEP.n0 VSS 0.12964f
C858 XBANK.XFAST.XSTART.NODEP.n1 VSS 2.16655f
C859 XBANK.XFAST.XSTART.NODEP.n2 VSS 0.31337f
C860 XBANK.XFAST.XSTART.NODEP.t1 VSS 0.1532f
C861 XBANK.XFAST.XSTART.NODEP.t4 VSS 0.19983f
C862 XBANK.XFAST.XSTART.NODEP.t2 VSS 0.1026f
C863 XBANK.XFAST.XSTART.NODEP.n3 VSS 1.4663f
C864 XBANK.XFAST.XSTART.NODEP.n4 VSS 0.68513f
C865 XBANK.XFAST.XSTART.NODEP.n5 VSS 0.06678f
C866 XBANK.XFAST.XSTART.NODEP.n6 VSS 0.04912f
C867 XBANK.XFAST.XSTART.NODEP.t0 VSS 0.1532f
C868 XBANK.XFAST.XSTART.NODEP.n7 VSS 0.04912f
C869 XBANK.XFAST.XSTART.NODEP.n8 VSS 0.02003f
C870 a_n31052_12300.t5 VSS 0.10956f
C871 a_n31052_12300.t7 VSS 26.1993f
C872 a_n31052_12300.n0 VSS 0.09371f
C873 a_n31052_12300.n1 VSS 0.06832f
C874 a_n31052_12300.n2 VSS 0.06832f
C875 a_n31052_12300.t2 VSS 0.06971f
C876 a_n31052_12300.t3 VSS 0.06971f
C877 a_n31052_12300.n3 VSS 0.25389f
C878 a_n31052_12300.t1 VSS 0.05836f
C879 a_n31052_12300.t0 VSS 0.05836f
C880 a_n31052_12300.n4 VSS 0.22282f
C881 a_n31052_12300.n5 VSS 1.79664f
C882 a_n31052_12300.n6 VSS 0.05144f
C883 a_n31052_12300.n7 VSS 0.05026f
C884 a_n31052_12300.n8 VSS 0.25628f
C885 a_n31052_12300.n9 VSS 0.05131f
C886 a_n31052_12300.n10 VSS 0.05039f
C887 a_n31052_12300.t4 VSS 0.652f
C888 a_n31052_12300.n11 VSS 0.09371f
C889 a_n31052_12300.n12 VSS 0.10133f
C890 a_n31052_12300.n13 VSS 0.51061f
C891 a_n31052_12300.t6 VSS 0.10956f
C892 XBANK.XFAST.XSTART.NODEN.t0 VSS 0.0997f
C893 XBANK.XFAST.XSTART.NODEN.n0 VSS 0.19707f
C894 XBANK.XFAST.XSTART.NODEN.n1 VSS 3.31507f
C895 XBANK.XFAST.XSTART.NODEN.n2 VSS 0.51624f
C896 XBANK.XFAST.XSTART.NODEN.t3 VSS 0.23284f
C897 XBANK.XFAST.XSTART.NODEN.n3 VSS 0.07537f
C898 XBANK.XFAST.XSTART.NODEN.t4 VSS 0.23284f
C899 XBANK.XFAST.XSTART.NODEN.n4 VSS 0.07466f
C900 XBANK.XFAST.XSTART.NODEN.n5 VSS 0.06344f
C901 XBANK.XFAST.XSTART.NODEN.t2 VSS 0.22528f
C902 XBANK.XFAST.XSTART.NODEN.t1 VSS 0.48511f
C903 XBANK.XFAST.XSTART.NODEN.n6 VSS 2.54172f
C904 a_n28972_12400.t0 VSS 0.25282f
C905 a_n28972_12400.t2 VSS 0.26826f
C906 a_n28972_12400.t3 VSS 0.22936f
C907 a_n28972_12400.n0 VSS 1.11704f
C908 a_n28972_12400.n1 VSS 0.30058f
C909 a_n28972_12400.t1 VSS 0.25282f
C910 XBANK.XGAIN.XSTART.NODEP.t4 VSS 0.06867f
C911 XBANK.XGAIN.XSTART.NODEP.n0 VSS 0.12809f
C912 XBANK.XGAIN.XSTART.NODEP.n1 VSS 2.14068f
C913 XBANK.XGAIN.XSTART.NODEP.n2 VSS 0.31652f
C914 XBANK.XGAIN.XSTART.NODEP.t3 VSS 0.15126f
C915 XBANK.XGAIN.XSTART.NODEP.t2 VSS 0.19762f
C916 XBANK.XGAIN.XSTART.NODEP.t1 VSS 0.09999f
C917 XBANK.XGAIN.XSTART.NODEP.n3 VSS 1.41536f
C918 XBANK.XGAIN.XSTART.NODEP.n4 VSS 0.67695f
C919 XBANK.XGAIN.XSTART.NODEP.n5 VSS 0.06598f
C920 XBANK.XGAIN.XSTART.NODEP.n6 VSS 0.04853f
C921 XBANK.XGAIN.XSTART.NODEP.t0 VSS 0.15126f
C922 XBANK.XGAIN.XSTART.NODEP.n7 VSS 0.04853f
C923 XBANK.XGAIN.XSTART.NODEP.n8 VSS 0.01979f
C924 a_24948_12300.n0 VSS 0.05638f
C925 a_24948_12300.t5 VSS 0.08005f
C926 a_24948_12300.t4 VSS 0.08005f
C927 a_24948_12300.n1 VSS 0.37074f
C928 a_24948_12300.t3 VSS 0.46985f
C929 a_24948_12300.n2 VSS 0.09033f
C930 a_24948_12300.n3 VSS 0.07488f
C931 a_24948_12300.t1 VSS 0.0729f
C932 a_24948_12300.t2 VSS 0.0729f
C933 a_24948_12300.n4 VSS 0.27826f
C934 a_24948_12300.t0 VSS 0.0616f
C935 a_24948_12300.t7 VSS 0.0616f
C936 a_24948_12300.n5 VSS 0.2442f
C937 a_24948_12300.n6 VSS 2.02754f
C938 a_24948_12300.n7 VSS 0.05509f
C939 a_24948_12300.n8 VSS 0.33937f
C940 a_24948_12300.n9 VSS 0.05624f
C941 a_24948_12300.n10 VSS 0.05522f
C942 a_24948_12300.n11 VSS 0.07488f
C943 a_24948_12300.n12 VSS 0.09825f
C944 a_24948_12300.n13 VSS 0.09033f
C945 a_24948_12300.t6 VSS 0.46985f
C946 XBANK.XGAIN.XSTART.NODEN.t2 VSS 0.09883f
C947 XBANK.XGAIN.XSTART.NODEN.n0 VSS 0.19519f
C948 XBANK.XGAIN.XSTART.NODEN.n1 VSS 3.28353f
C949 XBANK.XGAIN.XSTART.NODEN.n2 VSS 0.52184f
C950 XBANK.XGAIN.XSTART.NODEN.t1 VSS 0.23025f
C951 XBANK.XGAIN.XSTART.NODEN.n3 VSS 0.07465f
C952 XBANK.XGAIN.XSTART.NODEN.t3 VSS 0.23025f
C953 XBANK.XGAIN.XSTART.NODEN.n4 VSS 0.07395f
C954 XBANK.XGAIN.XSTART.NODEN.n5 VSS 0.06284f
C955 XBANK.XGAIN.XSTART.NODEN.t0 VSS 0.22307f
C956 XBANK.XGAIN.XSTART.NODEN.t4 VSS 0.46377f
C957 XBANK.XGAIN.XSTART.NODEN.n6 VSS 2.48119f
C958 a_27028_12400.t0 VSS 0.16978f
C959 a_27028_12400.t2 VSS 0.28023f
C960 a_27028_12400.t3 VSS 0.2408f
C961 a_27028_12400.n0 VSS 1.21648f
C962 a_27028_12400.n1 VSS 0.32499f
C963 a_27028_12400.t1 VSS 13.89058f
C964 a_n31052_n500.t5 VSS 0.10956f
C965 a_n31052_n500.t7 VSS 0.652f
C966 a_n31052_n500.n0 VSS 0.09371f
C967 a_n31052_n500.n1 VSS 0.06832f
C968 a_n31052_n500.n2 VSS 0.06832f
C969 a_n31052_n500.t2 VSS 0.06645f
C970 a_n31052_n500.t3 VSS 0.06645f
C971 a_n31052_n500.n3 VSS 0.25389f
C972 a_n31052_n500.t1 VSS 0.05623f
C973 a_n31052_n500.t0 VSS 0.05623f
C974 a_n31052_n500.n4 VSS 0.22282f
C975 a_n31052_n500.n5 VSS 1.79664f
C976 a_n31052_n500.n6 VSS 0.05144f
C977 a_n31052_n500.n7 VSS 0.05026f
C978 a_n31052_n500.n8 VSS 0.25628f
C979 a_n31052_n500.n9 VSS 0.05131f
C980 a_n31052_n500.n10 VSS 0.05039f
C981 a_n31052_n500.t4 VSS 0.652f
C982 a_n31052_n500.n11 VSS 0.09371f
C983 a_n31052_n500.n12 VSS 0.10133f
C984 a_n31052_n500.n13 VSS 0.51061f
C985 a_n31052_n500.t6 VSS 0.10956f
C986 a_n28972_n400.t0 VSS 0.25282f
C987 a_n28972_n400.t2 VSS 0.29571f
C988 a_n28972_n400.t3 VSS 0.23181f
C989 a_n28972_n400.n0 VSS 1.11704f
C990 a_n28972_n400.n1 VSS 0.30058f
C991 a_n28972_n400.t1 VSS 0.25282f
C992 a_24948_n500.n0 VSS 0.05638f
C993 a_24948_n500.t3 VSS 0.08005f
C994 a_24948_n500.t2 VSS 0.08005f
C995 a_24948_n500.n1 VSS 0.37074f
C996 a_24948_n500.t1 VSS 0.46985f
C997 a_24948_n500.n2 VSS 0.09033f
C998 a_24948_n500.n3 VSS 0.07488f
C999 a_24948_n500.t5 VSS 0.06929f
C1000 a_24948_n500.t7 VSS 0.06929f
C1001 a_24948_n500.n4 VSS 0.27826f
C1002 a_24948_n500.t6 VSS 0.0594f
C1003 a_24948_n500.t0 VSS 0.0594f
C1004 a_24948_n500.n5 VSS 0.2442f
C1005 a_24948_n500.n6 VSS 2.02754f
C1006 a_24948_n500.n7 VSS 0.05509f
C1007 a_24948_n500.n8 VSS 0.33937f
C1008 a_24948_n500.n9 VSS 0.05624f
C1009 a_24948_n500.n10 VSS 0.05522f
C1010 a_24948_n500.n11 VSS 0.07488f
C1011 a_24948_n500.n12 VSS 0.09825f
C1012 a_24948_n500.n13 VSS 0.09033f
C1013 a_24948_n500.t4 VSS 0.46985f
C1014 a_27028_n400.t1 VSS 0.16978f
C1015 a_27028_n400.t3 VSS 0.30826f
C1016 a_27028_n400.t0 VSS 0.24341f
C1017 a_27028_n400.n0 VSS 1.21648f
C1018 a_27028_n400.n1 VSS 0.32499f
C1019 a_27028_n400.t2 VSS 0.16978f
C1020 a_n43400_n37702.t1 VSS 0.41127f
C1021 a_n43400_n37702.t0 VSS 0.23035f
C1022 a_n43400_n37702.t4 VSS 0.40569f
C1023 a_n43400_n37702.t3 VSS 0.4057f
C1024 a_n43400_n37702.n0 VSS 0.38558f
C1025 a_n43400_n37702.n1 VSS 1.96457f
C1026 a_n43400_n37702.n2 VSS 0.27469f
C1027 a_n43400_n37702.t2 VSS 0.41127f
C1028 a_n40400_n37702.t1 VSS 0.40602f
C1029 a_n40400_n37702.t0 VSS 0.23054f
C1030 a_n40400_n37702.t4 VSS 0.41173f
C1031 a_n40400_n37702.t3 VSS 0.41173f
C1032 a_n40400_n37702.n0 VSS 0.27493f
C1033 a_n40400_n37702.n1 VSS 1.96623f
C1034 a_n40400_n37702.n2 VSS 0.38591f
C1035 a_n40400_n37702.t2 VSS 0.40601f
C1036 a_n37400_n37702.t0 VSS 0.40602f
C1037 a_n37400_n37702.t2 VSS 0.23054f
C1038 a_n37400_n37702.t4 VSS 0.41173f
C1039 a_n37400_n37702.t3 VSS 0.41173f
C1040 a_n37400_n37702.n0 VSS 0.27493f
C1041 a_n37400_n37702.n1 VSS 1.96623f
C1042 a_n37400_n37702.n2 VSS 0.38591f
C1043 a_n37400_n37702.t1 VSS 0.40601f
C1044 a_n34400_n37702.t0 VSS 0.41173f
C1045 a_n34400_n37702.t2 VSS 0.23054f
C1046 a_n34400_n37702.t4 VSS 0.40601f
C1047 a_n34400_n37702.t3 VSS 0.40602f
C1048 a_n34400_n37702.n0 VSS 0.38591f
C1049 a_n34400_n37702.n1 VSS 1.96623f
C1050 a_n34400_n37702.n2 VSS 0.27493f
C1051 a_n34400_n37702.t1 VSS 0.41173f
C1052 a_n31400_n37702.t1 VSS 0.40602f
C1053 a_n31400_n37702.t0 VSS 0.23054f
C1054 a_n31400_n37702.t4 VSS 0.41173f
C1055 a_n31400_n37702.t3 VSS 0.41173f
C1056 a_n31400_n37702.n0 VSS 0.27493f
C1057 a_n31400_n37702.n1 VSS 1.96623f
C1058 a_n31400_n37702.n2 VSS 0.38591f
C1059 a_n31400_n37702.t2 VSS 0.40601f
C1060 a_n25000_n37702.t1 VSS 0.40601f
C1061 a_n25000_n37702.t0 VSS 0.23054f
C1062 a_n25000_n37702.t4 VSS 0.41173f
C1063 a_n25000_n37702.t3 VSS 0.41173f
C1064 a_n25000_n37702.n0 VSS 0.27493f
C1065 a_n25000_n37702.n1 VSS 1.96623f
C1066 a_n25000_n37702.n2 VSS 0.38591f
C1067 a_n25000_n37702.t2 VSS 0.40602f
C1068 a_n22000_n37702.t1 VSS 0.41173f
C1069 a_n22000_n37702.t0 VSS 0.23054f
C1070 a_n22000_n37702.t4 VSS 0.40602f
C1071 a_n22000_n37702.t3 VSS 0.40601f
C1072 a_n22000_n37702.n0 VSS 0.38591f
C1073 a_n22000_n37702.n1 VSS 1.96623f
C1074 a_n22000_n37702.n2 VSS 0.27493f
C1075 a_n22000_n37702.t2 VSS 0.41173f
C1076 a_n19000_n37702.t0 VSS 0.41173f
C1077 a_n19000_n37702.t4 VSS 0.23054f
C1078 a_n19000_n37702.t3 VSS 0.40602f
C1079 a_n19000_n37702.t2 VSS 0.40601f
C1080 a_n19000_n37702.n0 VSS 0.38591f
C1081 a_n19000_n37702.n1 VSS 1.96623f
C1082 a_n19000_n37702.n2 VSS 0.27493f
C1083 a_n19000_n37702.t1 VSS 0.41173f
C1084 a_n16000_n37702.t0 VSS 0.40601f
C1085 a_n16000_n37702.t2 VSS 0.23054f
C1086 a_n16000_n37702.t4 VSS 0.41173f
C1087 a_n16000_n37702.t3 VSS 0.41173f
C1088 a_n16000_n37702.n0 VSS 0.27493f
C1089 a_n16000_n37702.n1 VSS 1.96623f
C1090 a_n16000_n37702.n2 VSS 0.38591f
C1091 a_n16000_n37702.t1 VSS 0.40602f
C1092 a_n13000_n37702.t1 VSS 0.41166f
C1093 a_n13000_n37702.t0 VSS 0.23052f
C1094 a_n13000_n37702.t4 VSS 0.40598f
C1095 a_n13000_n37702.t3 VSS 0.40597f
C1096 a_n13000_n37702.n0 VSS 0.38586f
C1097 a_n13000_n37702.n1 VSS 1.96602f
C1098 a_n13000_n37702.n2 VSS 0.2749f
C1099 a_n13000_n37702.t2 VSS 0.41165f
C1100 a_12600_n37702.t0 VSS 0.40598f
C1101 a_12600_n37702.t4 VSS 0.23052f
C1102 a_12600_n37702.t3 VSS 0.41169f
C1103 a_12600_n37702.t2 VSS 0.41169f
C1104 a_12600_n37702.n0 VSS 0.2749f
C1105 a_12600_n37702.n1 VSS 1.96602f
C1106 a_12600_n37702.n2 VSS 0.38586f
C1107 a_12600_n37702.t1 VSS 0.40597f
C1108 a_15600_n37702.t0 VSS 0.40602f
C1109 a_15600_n37702.t4 VSS 0.23054f
C1110 a_15600_n37702.t3 VSS 0.41173f
C1111 a_15600_n37702.t2 VSS 0.41173f
C1112 a_15600_n37702.n0 VSS 0.27493f
C1113 a_15600_n37702.n1 VSS 1.96623f
C1114 a_15600_n37702.n2 VSS 0.38591f
C1115 a_15600_n37702.t1 VSS 0.40601f
C1116 a_18600_n37702.t0 VSS 0.40602f
C1117 a_18600_n37702.t4 VSS 0.23054f
C1118 a_18600_n37702.t3 VSS 0.41173f
C1119 a_18600_n37702.t2 VSS 0.41173f
C1120 a_18600_n37702.n0 VSS 0.27493f
C1121 a_18600_n37702.n1 VSS 1.96623f
C1122 a_18600_n37702.n2 VSS 0.38591f
C1123 a_18600_n37702.t1 VSS 0.40601f
C1124 a_21600_n37702.t0 VSS 0.40602f
C1125 a_21600_n37702.t2 VSS 0.23054f
C1126 a_21600_n37702.t4 VSS 0.41173f
C1127 a_21600_n37702.t3 VSS 0.41173f
C1128 a_21600_n37702.n0 VSS 0.27493f
C1129 a_21600_n37702.n1 VSS 1.96623f
C1130 a_21600_n37702.n2 VSS 0.38591f
C1131 a_21600_n37702.t1 VSS 0.40601f
C1132 a_24600_n37702.t0 VSS 0.41173f
C1133 a_24600_n37702.t2 VSS 0.23054f
C1134 a_24600_n37702.t4 VSS 0.40601f
C1135 a_24600_n37702.t3 VSS 0.40602f
C1136 a_24600_n37702.n0 VSS 0.38591f
C1137 a_24600_n37702.n1 VSS 1.96623f
C1138 a_24600_n37702.n2 VSS 0.27493f
C1139 a_24600_n37702.t1 VSS 0.41173f
C1140 a_31000_n37702.t0 VSS 0.41173f
C1141 a_31000_n37702.t4 VSS 0.23054f
C1142 a_31000_n37702.t3 VSS 0.40602f
C1143 a_31000_n37702.t2 VSS 0.40601f
C1144 a_31000_n37702.n0 VSS 0.38591f
C1145 a_31000_n37702.n1 VSS 1.96623f
C1146 a_31000_n37702.n2 VSS 0.27493f
C1147 a_31000_n37702.t1 VSS 0.41173f
C1148 a_34000_n37702.t0 VSS 0.40601f
C1149 a_34000_n37702.t2 VSS 0.23054f
C1150 a_34000_n37702.t4 VSS 0.41173f
C1151 a_34000_n37702.t3 VSS 0.41173f
C1152 a_34000_n37702.n0 VSS 0.27493f
C1153 a_34000_n37702.n1 VSS 1.96623f
C1154 a_34000_n37702.n2 VSS 0.38591f
C1155 a_34000_n37702.t1 VSS 0.40602f
C1156 a_37000_n37702.t1 VSS 0.41173f
C1157 a_37000_n37702.t0 VSS 0.23054f
C1158 a_37000_n37702.t4 VSS 0.40602f
C1159 a_37000_n37702.t3 VSS 0.40601f
C1160 a_37000_n37702.n0 VSS 0.38591f
C1161 a_37000_n37702.n1 VSS 1.96623f
C1162 a_37000_n37702.n2 VSS 0.27493f
C1163 a_37000_n37702.t2 VSS 0.41173f
C1164 a_40000_n37702.t1 VSS 0.41173f
C1165 a_40000_n37702.t0 VSS 0.23054f
C1166 a_40000_n37702.t4 VSS 0.40602f
C1167 a_40000_n37702.t3 VSS 0.40601f
C1168 a_40000_n37702.n0 VSS 0.38591f
C1169 a_40000_n37702.n1 VSS 1.96623f
C1170 a_40000_n37702.n2 VSS 0.27493f
C1171 a_40000_n37702.t2 VSS 0.41173f
C1172 a_43000_n37702.t1 VSS 0.40569f
C1173 a_43000_n37702.t0 VSS 0.23035f
C1174 a_43000_n37702.t4 VSS 0.41127f
C1175 a_43000_n37702.t3 VSS 0.41127f
C1176 a_43000_n37702.n0 VSS 0.27469f
C1177 a_43000_n37702.n1 VSS 1.96457f
C1178 a_43000_n37702.n2 VSS 0.38558f
C1179 a_43000_n37702.t2 VSS 0.4057f
C1180 VSS.t206 VSS 0.014f
C1181 VSS.t205 VSS 0.01448f
C1182 VSS.t208 VSS 0.01448f
C1183 VSS.t207 VSS 0.014f
C1184 VSS.t178 VSS 0.01235f
C1185 VSS.t176 VSS 0.01234f
C1186 VSS.t182 VSS 0.01234f
C1187 VSS.t180 VSS 0.01235f
C1188 VSS.t253 VSS 0.26459f
C1189 VSS.t252 VSS 0.26459f
C1190 VSS.t261 VSS 0.25581f
C1191 VSS.t260 VSS 0.25581f
C1192 VSS.t231 VSS 0.02512f
C1193 VSS.t230 VSS 0.02549f
C1194 VSS.t233 VSS 0.02549f
C1195 VSS.t232 VSS 0.02512f
C1196 VSS.t21 VSS 0.051f
C1197 VSS.t20 VSS 0.0504f
C1198 VSS.t19 VSS 0.0504f
C1199 VSS.t11 VSS 0.051f
C1200 VSS.t18 VSS 0.051f
C1201 VSS.t16 VSS 0.0504f
C1202 VSS.t14 VSS 0.0504f
C1203 VSS.t12 VSS 0.051f
C1204 VSS.t188 VSS 0.28489f
C1205 VSS.t187 VSS 0.28489f
C1206 VSS.t86 VSS 0.43413f
C1207 VSS.t85 VSS 0.43413f
C1208 VSS.t173 VSS 13.7208f
C1209 VSS.t277 VSS 0.26168f
C1210 VSS.t276 VSS 0.26168f
C1211 VSS.t52 VSS 0.38643f
C1212 VSS.t51 VSS 0.38643f
C1213 VSS.t28 VSS 0.19132f
C1214 VSS.t27 VSS 0.19132f
C1215 VSS.t279 VSS 0.25903f
C1216 VSS.t278 VSS 0.25903f
C1217 VSS.t141 VSS 25.45585f
C1218 VSS.t119 VSS 0.03021f
C1219 VSS.t129 VSS 0.02978f
C1220 VSS.t118 VSS 0.02978f
C1221 VSS.t125 VSS 0.03021f
C1222 VSS.t127 VSS 0.03021f
C1223 VSS.t123 VSS 0.02978f
C1224 VSS.t121 VSS 0.02978f
C1225 VSS.t116 VSS 0.03021f
C1226 VSS.t46 VSS 0.0102f
C1227 VSS.t44 VSS 0.01055f
C1228 VSS.t50 VSS 0.01055f
C1229 VSS.t48 VSS 0.0102f
C1230 VSS.t55 VSS 0.28512f
C1231 VSS.t54 VSS 0.28512f
C1232 VSS.t97 VSS 0.25843f
C1233 VSS.t96 VSS 0.25843f
C1234 VSS.t272 VSS 0.31581f
C1235 VSS.t273 VSS 0.31581f
C1236 VSS.t194 VSS 0.43292f
C1237 VSS.t195 VSS 0.43292f
C1238 VSS.t78 VSS 14.0013f
C1239 VSS.t114 VSS 0.48007f
C1240 VSS.t113 VSS 0.48007f
C1241 VSS.t248 VSS 0.29508f
C1242 VSS.t247 VSS 0.29508f
C1243 VSS.t296 VSS 25.5473f
C1244 VSS.t274 VSS 0.28924f
C1245 VSS.t275 VSS 0.28924f
C1246 VSS.t251 VSS 0.29852f
C1247 VSS.t250 VSS 0.29852f
C1248 VDD.t5 VSS 0.0123f
C1249 VDD.t19 VSS 0.0123f
C1250 VDD.n0 VSS 0.4864f
C1251 VDD.t0 VSS 0.0123f
C1252 VDD.t14 VSS 0.0123f
C1253 VDD.n1 VSS 0.57553f
C1254 VDD.t3 VSS 0.0123f
C1255 VDD.t13 VSS 0.0123f
C1256 VDD.n2 VSS 0.48695f
C1257 VDD.n3 VSS 0.41357f
C1258 VDD.n4 VSS 0.2021f
C1259 VDD.t9 VSS 0.0123f
C1260 VDD.t10 VSS 0.0123f
C1261 VDD.n5 VSS 0.57499f
C1262 VDD.n6 VSS 0.67748f
C1263 VDD.t7 VSS 0.01956f
C1264 VDD.t27 VSS 0.01866f
C1265 VDD.n7 VSS 0.10317f
C1266 VDD.t23 VSS 0.02153f
C1267 VDD.t15 VSS 0.01891f
C1268 VDD.n8 VSS 0.11934f
C1269 VDD.n9 VSS 0.05809f
C1270 VDD.t24 VSS 0.0123f
C1271 VDD.t21 VSS 0.0123f
C1272 VDD.n10 VSS 0.48583f
C1273 VDD.t26 VSS 0.0123f
C1274 VDD.t12 VSS 0.0123f
C1275 VDD.n11 VSS 0.57497f
C1276 VDD.t16 VSS 0.0123f
C1277 VDD.t8 VSS 0.0123f
C1278 VDD.n12 VSS 0.48639f
C1279 VDD.n13 VSS 0.41357f
C1280 VDD.n14 VSS 0.2021f
C1281 VDD.t22 VSS 0.0123f
C1282 VDD.t6 VSS 0.0123f
C1283 VDD.n15 VSS 0.57442f
C1284 VDD.n16 VSS 0.58074f
C1285 VDD.t20 VSS 0.01426f
C1286 VDD.t1 VSS 0.0135f
C1287 VDD.n17 VSS 0.0748f
C1288 VDD.t11 VSS 0.01426f
C1289 VDD.t2 VSS 0.0135f
C1290 VDD.n18 VSS 0.0748f
C1291 VDD.t25 VSS 0.01505f
C1292 VDD.t17 VSS 0.01237f
C1293 VDD.n19 VSS 0.18233f
C1294 VDD.t4 VSS 0.01237f
C1295 VDD.n20 VSS 0.52925f
C1296 VDD.t18 VSS 0.01237f
C1297 VDD.n21 VSS 1.9679f
C1298 VDD.n22 VSS 2.30125f
C1299 VDD.n23 VSS 0.98292f
C1300 VDD.n24 VSS 1.27431f
C1301 VDD.n25 VSS 0.47006f
C1302 DIV_P.t0 VSS 0.12795f
C1303 DIV_P.n0 VSS 0.32748f
C1304 DIV_P.n1 VSS 0.91135f
C1305 DIV_P.t4 VSS 0.09809f
C1306 DIV_P.t3 VSS 0.09817f
C1307 DIV_P.n2 VSS 0.76379f
C1308 DIV_P.n3 VSS 0.06073f
C1309 DIV_P.t5 VSS 0.30699f
C1310 DIV_P.n4 VSS 0.08536f
C1311 DIV_P.t6 VSS 0.30699f
C1312 DIV_P.n5 VSS 0.08536f
C1313 DIV_P.n6 VSS 0.07257f
C1314 DIV_P.n7 VSS 1.28134f
C1315 DIV_P.n8 VSS 1.43792f
C1316 DIV_P.t1 VSS 0.31427f
C1317 DIV_P.t2 VSS 0.31419f
C1318 DIV_P.n9 VSS 0.1975f
C1319 DIV_P.n10 VSS 3.50172f
C1320 DIV_N.t4 VSS 0.12568f
C1321 DIV_N.t1 VSS 0.29327f
C1322 DIV_N.t3 VSS 0.29336f
C1323 DIV_N.n0 VSS 0.19401f
C1324 DIV_N.n1 VSS 0.89435f
C1325 DIV_N.n2 VSS 0.26181f
C1326 DIV_N.n3 VSS 0.77092f
C1327 DIV_N.n4 VSS 0.08186f
C1328 DIV_N.t2 VSS 0.3032f
C1329 DIV_N.t0 VSS 0.3032f
C1330 DIV_N.n5 VSS 0.08385f
C1331 DIV_N.n6 VSS 0.08385f
C1332 DIV_N.n7 VSS 0.07129f
C1333 DIV_N.n8 VSS 0.2619f
C1334 DIV_N.n9 VSS 2.67231f
C1335 DIV_BIAS.n0 VSS 0.02666f
C1336 DIV_BIAS.n1 VSS 0.0286f
C1337 DIV_BIAS.n2 VSS 0.0286f
C1338 DIV_BIAS.n3 VSS 0.02666f
C1339 DIV_BIAS.n4 VSS 0.2352f
C1340 DIV_BIAS.n5 VSS 0.02666f
C1341 DIV_BIAS.n6 VSS 0.0286f
C1342 DIV_BIAS.n7 VSS 0.0286f
C1343 DIV_BIAS.n8 VSS 0.02666f
C1344 DIV_BIAS.n9 VSS 0.08112f
C1345 DIV_BIAS.n10 VSS 0.99401f
C1346 DIV_BIAS.n11 VSS 0.14454f
C1347 DIV_RESET.n0 VSS 0.13564f
C1348 DIV_RESET.n1 VSS 0.13564f
C1349 DIV_RESET.n2 VSS 0.91432f
C1350 REST_BIAS.n0 VSS 0.04333f
C1351 REST_BIAS.n1 VSS 0.04603f
C1352 REST_BIAS.n2 VSS 0.04603f
C1353 REST_BIAS.n3 VSS 0.04333f
C1354 REST_BIAS.n4 VSS 0.32667f
C1355 REST_BIAS.n5 VSS 0.04333f
C1356 REST_BIAS.n6 VSS 0.04603f
C1357 REST_BIAS.n7 VSS 0.04603f
C1358 REST_BIAS.n8 VSS 0.04333f
C1359 REST_BIAS.n9 VSS 0.1152f
C1360 REST_BIAS.n10 VSS 1.25952f
C1361 SEL_BUF.n0 VSS 0.02249f
C1362 SEL_BUF.n1 VSS 0.02413f
C1363 SEL_BUF.n2 VSS 0.02413f
C1364 SEL_BUF.n3 VSS 0.02249f
C1365 SEL_BUF.n4 VSS 0.07784f
C1366 SEL_A.n0 VSS 0.01531f
C1367 SEL_A.n1 VSS 0.01724f
C1368 SEL_A.n2 VSS 0.01724f
C1369 SEL_A.n3 VSS 0.01531f
C1370 SEL_A.n4 VSS 0.12574f
C1371 SEL_B.n0 VSS 0.01115f
C1372 SEL_B.n1 VSS 0.01255f
C1373 SEL_B.n2 VSS 0.01255f
C1374 SEL_B.n3 VSS 0.01115f
C1375 SEL_B.n4 VSS 0.12976f
C1376 VREFL.t31 VSS 0.09625f
C1377 VREFL.t30 VSS 0.09624f
C1378 VREFL.n0 VSS 0.3804f
C1379 VREFL.t38 VSS 0.09625f
C1380 VREFL.t39 VSS 0.09624f
C1381 VREFL.n1 VSS 0.27658f
C1382 VREFL.n2 VSS 1.3679f
C1383 VREFL.t40 VSS 0.09625f
C1384 VREFL.t41 VSS 0.09624f
C1385 VREFL.n3 VSS 0.27658f
C1386 VREFL.n4 VSS 0.77299f
C1387 VREFL.t7 VSS 0.09625f
C1388 VREFL.t8 VSS 0.09624f
C1389 VREFL.n5 VSS 0.27658f
C1390 VREFL.n6 VSS 0.77299f
C1391 VREFL.t21 VSS 0.09625f
C1392 VREFL.t20 VSS 0.09624f
C1393 VREFL.n7 VSS 0.27658f
C1394 VREFL.n8 VSS 0.67399f
C1395 VREFL.t6 VSS 0.81702f
C1396 VREFL.n9 VSS 1.98912f
C1397 VREFL.t17 VSS 0.81702f
C1398 VREFL.n10 VSS 1.98912f
C1399 VREFL.t26 VSS 0.09624f
C1400 VREFL.t27 VSS 0.09625f
C1401 VREFL.n11 VSS 0.27658f
C1402 VREFL.n12 VSS 0.67399f
C1403 VREFL.t3 VSS 0.09624f
C1404 VREFL.t2 VSS 0.09625f
C1405 VREFL.n13 VSS 0.27658f
C1406 VREFL.n14 VSS 0.77299f
C1407 VREFL.t15 VSS 0.09624f
C1408 VREFL.t16 VSS 0.09625f
C1409 VREFL.n15 VSS 0.27658f
C1410 VREFL.n16 VSS 0.77299f
C1411 VREFL.t5 VSS 0.09624f
C1412 VREFL.t4 VSS 0.09625f
C1413 VREFL.n17 VSS 0.27658f
C1414 VREFL.n18 VSS 0.77299f
C1415 VREFL.t10 VSS 0.09624f
C1416 VREFL.t9 VSS 0.09625f
C1417 VREFL.n19 VSS 0.27658f
C1418 VREFL.n20 VSS 2.10945f
C1419 VREFL.t36 VSS 0.09624f
C1420 VREFL.t37 VSS 0.09625f
C1421 VREFL.n21 VSS 0.3804f
C1422 VREFL.t11 VSS 0.09624f
C1423 VREFL.t12 VSS 0.09625f
C1424 VREFL.n22 VSS 0.27658f
C1425 VREFL.n23 VSS 1.3679f
C1426 VREFL.t0 VSS 0.09624f
C1427 VREFL.t1 VSS 0.09625f
C1428 VREFL.n24 VSS 0.27658f
C1429 VREFL.n25 VSS 0.77299f
C1430 VREFL.t42 VSS 0.09624f
C1431 VREFL.t43 VSS 0.09625f
C1432 VREFL.n26 VSS 0.27658f
C1433 VREFL.n27 VSS 0.77299f
C1434 VREFL.t25 VSS 0.09624f
C1435 VREFL.t24 VSS 0.09625f
C1436 VREFL.n28 VSS 0.27658f
C1437 VREFL.n29 VSS 0.67399f
C1438 VREFL.t13 VSS 0.81702f
C1439 VREFL.n30 VSS 1.98912f
C1440 VREFL.t14 VSS 0.81702f
C1441 VREFL.n31 VSS 1.98912f
C1442 VREFL.t28 VSS 0.09625f
C1443 VREFL.t29 VSS 0.09624f
C1444 VREFL.n32 VSS 0.27658f
C1445 VREFL.n33 VSS 0.67399f
C1446 VREFL.t32 VSS 0.09625f
C1447 VREFL.t33 VSS 0.09624f
C1448 VREFL.n34 VSS 0.27658f
C1449 VREFL.n35 VSS 0.77299f
C1450 VREFL.t22 VSS 0.09625f
C1451 VREFL.t23 VSS 0.09624f
C1452 VREFL.n36 VSS 0.27658f
C1453 VREFL.n37 VSS 0.77299f
C1454 VREFL.t34 VSS 0.09625f
C1455 VREFL.t35 VSS 0.09624f
C1456 VREFL.n38 VSS 0.27658f
C1457 VREFL.n39 VSS 0.77299f
C1458 VREFL.t18 VSS 0.09625f
C1459 VREFL.t19 VSS 0.09624f
C1460 VREFL.n40 VSS 0.27658f
C1461 VREFL.n41 VSS 1.86195f
C1462 F_A4.n0 VSS 0.16193f
C1463 F_A3.n0 VSS 0.1626f
C1464 F_A2.n0 VSS 0.1626f
C1465 F_A1.n0 VSS 0.1626f
C1466 F_A0.n0 VSS 0.1626f
C1467 F_B0.n0 VSS 0.1626f
C1468 F_B1.n0 VSS 0.1626f
C1469 F_B2.n0 VSS 0.1626f
C1470 F_B3.n0 VSS 0.1626f
C1471 F_B4.n0 VSS 0.16245f
C1472 VREFH.t31 VSS 0.1271f
C1473 VREFH.t30 VSS 0.12711f
C1474 VREFH.n0 VSS 0.52242f
C1475 VREFH.t36 VSS 0.12725f
C1476 VREFH.t37 VSS 0.12725f
C1477 VREFH.n1 VSS 0.37984f
C1478 VREFH.n2 VSS 1.87863f
C1479 VREFH.t23 VSS 0.12725f
C1480 VREFH.t22 VSS 0.12725f
C1481 VREFH.n3 VSS 0.37984f
C1482 VREFH.n4 VSS 1.06159f
C1483 VREFH.t29 VSS 0.12725f
C1484 VREFH.t28 VSS 0.12725f
C1485 VREFH.n5 VSS 0.37984f
C1486 VREFH.n6 VSS 1.06159f
C1487 VREFH.t20 VSS 0.12725f
C1488 VREFH.t21 VSS 0.12725f
C1489 VREFH.n7 VSS 0.37984f
C1490 VREFH.n8 VSS 1.63942f
C1491 VREFH.t11 VSS 0.12725f
C1492 VREFH.t10 VSS 0.12725f
C1493 VREFH.n9 VSS 0.37984f
C1494 VREFH.n10 VSS 1.63942f
C1495 VREFH.t9 VSS 0.12725f
C1496 VREFH.t8 VSS 0.12725f
C1497 VREFH.n11 VSS 0.37984f
C1498 VREFH.n12 VSS 1.06159f
C1499 VREFH.t18 VSS 0.12725f
C1500 VREFH.t17 VSS 0.12725f
C1501 VREFH.n13 VSS 0.37984f
C1502 VREFH.n14 VSS 1.06159f
C1503 VREFH.t7 VSS 0.12725f
C1504 VREFH.t6 VSS 0.12725f
C1505 VREFH.n15 VSS 0.37984f
C1506 VREFH.n16 VSS 1.06159f
C1507 VREFH.t12 VSS 0.12725f
C1508 VREFH.t13 VSS 0.12725f
C1509 VREFH.n17 VSS 0.37984f
C1510 VREFH.n18 VSS 2.89703f
C1511 VREFH.t24 VSS 0.12711f
C1512 VREFH.t25 VSS 0.1271f
C1513 VREFH.n19 VSS 0.52242f
C1514 VREFH.t14 VSS 0.12725f
C1515 VREFH.t16 VSS 0.12725f
C1516 VREFH.n20 VSS 0.37984f
C1517 VREFH.n21 VSS 1.87863f
C1518 VREFH.t15 VSS 0.12725f
C1519 VREFH.t26 VSS 0.12725f
C1520 VREFH.n22 VSS 0.37984f
C1521 VREFH.n23 VSS 1.06159f
C1522 VREFH.t27 VSS 0.12725f
C1523 VREFH.t33 VSS 0.12725f
C1524 VREFH.n24 VSS 0.37984f
C1525 VREFH.n25 VSS 1.06159f
C1526 VREFH.t3 VSS 0.12725f
C1527 VREFH.t34 VSS 0.12725f
C1528 VREFH.n26 VSS 0.37984f
C1529 VREFH.n27 VSS 1.63942f
C1530 VREFH.t5 VSS 0.12725f
C1531 VREFH.t32 VSS 0.12725f
C1532 VREFH.n28 VSS 0.37984f
C1533 VREFH.n29 VSS 1.63942f
C1534 VREFH.t39 VSS 0.12725f
C1535 VREFH.t38 VSS 0.12725f
C1536 VREFH.n30 VSS 0.37984f
C1537 VREFH.n31 VSS 1.06159f
C1538 VREFH.t19 VSS 0.12725f
C1539 VREFH.t0 VSS 0.12725f
C1540 VREFH.n32 VSS 0.37984f
C1541 VREFH.n33 VSS 1.06159f
C1542 VREFH.t2 VSS 0.12725f
C1543 VREFH.t1 VSS 0.12725f
C1544 VREFH.n34 VSS 0.37984f
C1545 VREFH.n35 VSS 1.06159f
C1546 VREFH.t35 VSS 0.12721f
C1547 VREFH.t4 VSS 0.12722f
C1548 VREFH.n36 VSS 0.37984f
C1549 VREFH.n37 VSS 2.55714f
C1550 F_A4B.n0 VSS 0.12145f
C1551 F_A3B.n0 VSS 0.12145f
C1552 F_A2B.n0 VSS 0.12145f
C1553 F_A1B.n0 VSS 0.12145f
C1554 F_A0B.n0 VSS 0.12145f
C1555 F_B0B.n0 VSS 0.12145f
C1556 F_B1B.n0 VSS 0.12145f
C1557 F_B2B.n0 VSS 0.12145f
C1558 F_B3B.n0 VSS 0.12145f
C1559 F_B4B.n0 VSS 0.12145f
C1560 G_A4.n0 VSS 0.1626f
C1561 G_A3.n0 VSS 0.1626f
C1562 G_A2.n0 VSS 0.1626f
C1563 G_A1.n0 VSS 0.1626f
C1564 G_A0.n0 VSS 0.1626f
C1565 G_B0.n0 VSS 0.1626f
C1566 G_B1.n0 VSS 0.1626f
C1567 G_B2.n0 VSS 0.1626f
C1568 G_B3.n0 VSS 0.1626f
C1569 G_B4.n0 VSS 0.16193f
C1570 G_A4B.n0 VSS 0.12145f
C1571 G_A3B.n0 VSS 0.12145f
C1572 G_A2B.n0 VSS 0.12145f
C1573 G_A1B.n0 VSS 0.12145f
C1574 G_A0B.n0 VSS 0.12145f
C1575 G_B0B.n0 VSS 0.12145f
C1576 G_B1B.n0 VSS 0.12145f
C1577 G_B2B.n0 VSS 0.12145f
C1578 G_B3B.n0 VSS 0.12145f
C1579 G_B4B.n0 VSS 0.12145f
.ends
