* PEX produced on Wed Aug 19 09:52:39 PM CEST 2026 using /foss/tools/sak/sak-pex.sh with m=3 and s=1 (extresist threshold=0 mOhm, minres=1 mOhm, mindelay=0 ps)
* NGSPICE file created from vco_bank_top_pex.ext - technology: gf180mcuD

.subckt vco_bank_top_pex VREFH VREFL VDD VSS F_A4 F_A4B F_A3 F_A3B F_A2 F_A2B F_A1
+ F_A1B F_A0 F_A0B F_B4 F_B4B F_B3 F_B3B F_B2 F_B2B F_B1 F_B1B F_B0 F_B0B G_A4 G_A4B
+ G_A3 G_A3B G_A2 G_A2B G_A1 G_A1B G_A0 G_A0B G_B4 G_B4B G_B3 G_B3B G_B2 G_B2B G_B1
+ G_B1B G_B0 G_B0B FAST_KICKP FAST_KICKN GAIN_KICKP GAIN_KICKN SEL_A SEL_B SEL_BUF
+ CLK_P CLK_N
X0 VREFH.t9 G_A0.t1 a_24600_n37702.t2 VSS.t0 nfet_03v3 ad=2.08p pd=8.52u as=3.52p ps=16.88u w=8u l=0.28u
X1 a_n5852_53500.t11 XSEL.A_P.t7 a_n5996_53500.t3 VSS.t232 nfet_03v3 ad=1.3p pd=5.52u as=2.2p ps=10.88u w=5u l=0.28u
X2 VREFL.t6 F_A0B.t1 a_n31400_n37702.t1 VSS.t55 nfet_03v3 ad=2.08p pd=8.52u as=3.52p ps=16.88u w=8u l=0.28u
X3 a_n31052_25100.t6 XFAST.X2.INN.t7 XFAST.XBUF.INN.t2 VSS.t34 nfet_03v3 ad=1.3p pd=5.52u as=2.2p ps=10.88u w=5u l=0.28u
X4 a_n28972_25200.t2 XFDAC.CTRL_B VSS.t116 VSS.t113 nfet_03v3 ad=2.64p pd=12.88u as=1.56p ps=6.52u w=6u l=0.28u
X5 XGAIN.XBUF.INP.t3 XGAIN.X2.INP.t6 a_24948_25100.t0 VSS.t8 nfet_03v3 ad=2.2p pd=10.88u as=1.3p ps=5.52u w=5u l=0.28u
X6 VSS.t211 XGAIN.XSTART.NODEP.t6 VSS.t210 VSS.t26 nfet_03v3 ad=1.76p pd=8.88u as=0 ps=0 w=4u l=3.45u
X7 XFDAC.CTRL_A a_n41900_n28902# VSS.t44 ppolyf_u r_width=2u r_length=20u
X8 a_27028_38000.t1 XSEL.B_P.t4 XSEL.B_N.t0 VSS.t21 nfet_03v3 ad=1.76p pd=8.88u as=1.76p ps=8.88u w=4u l=0.28u
X9 VREFL.t25 G_B1B.t1 a_34000_n37702.t0 VSS.t154 nfet_03v3 ad=2.08p pd=8.52u as=3.52p ps=16.88u w=8u l=0.28u
X10 a_n34400_n37702.t2 F_A1.t0 VREFH.t15 VSS.t63 nfet_03v3 ad=3.52p pd=16.88u as=2.08p ps=8.52u w=8u l=0.28u
X11 VDD.t18 XGAIN.XSTART.NODEP.t4 VSS.t26 ppolyf_u r_width=2u r_length=6.5u
X12 XGDAC.CTRL_B a_38500_n24800# VSS.t180 ppolyf_u r_width=2u r_length=20u
X13 a_27028_12400.t3 XGDAC.CTRL_B VSS.t196 VSS.t195 nfet_03v3 ad=1.76p pd=8.88u as=1.04p ps=4.52u w=4u l=0.28u
X14 VREFL.t13 F_B2B.t1 a_n19000_n37702.t0 VSS.t75 nfet_03v3 ad=2.08p pd=8.52u as=3.52p ps=16.88u w=8u l=0.28u
X15 a_n5996_53500.t6 XSEL.B_P.t8 a_n4252_53500.t0 VSS.t14 nfet_03v3 ad=2.2p pd=10.88u as=1.3p ps=5.52u w=5u l=0.28u
X16 a_n2796_53500.t7 XSEL.A_N.t6 a_n5852_53500.t10 VSS.t217 nfet_03v3 ad=2.2p pd=10.88u as=1.3p ps=5.52u w=5u l=0.28u
X17 VSS.t94 XGDAC.CTRL_A a_24948_25100.t4 VSS.t89 nfet_03v3 ad=2.6p pd=10.52u as=2.6p ps=10.52u w=10u l=0.28u
X18 VREFL.t19 F_A4B.t1 a_n43400_n37702.t0 VSS.t142 nfet_03v3 ad=2.08p pd=8.52u as=3.52p ps=16.88u w=8u l=0.28u
X19 CLK_N.t3 a_n2796_53500.t9 a_1748_53500.t8 VSS.t147 nfet_03v3 ad=2.2p pd=10.88u as=1.3p ps=5.52u w=5u l=0.28u
X20 VSS.t73 SEL_BUF.t1 a_1748_53500.t4 VSS.t72 nfet_03v3 ad=2.6p pd=10.52u as=2.6p ps=10.52u w=10u l=0.28u
X21 a_27028_38000.t0 XSEL.B_N.t4 XSEL.B_P.t0 VSS.t2 nfet_03v3 ad=1.76p pd=8.88u as=1.76p ps=8.88u w=4u l=0.28u
X22 a_27028_n400.t3 XGAIN.XSTART.NODEP.t5 XGAIN.XSTART.NODEN.t2 VSS.t21 nfet_03v3 ad=1.76p pd=8.88u as=1.76p ps=8.88u w=4u l=0.28u
X23 a_34000_n37702.t4 G_B1.t0 VREFH.t35 VSS.t155 nfet_03v3 ad=3.52p pd=16.88u as=2.08p ps=8.52u w=8u l=0.28u
X24 VDD.t6 XSEL.B_P.t1 VSS.t26 ppolyf_u r_width=2u r_length=6.5u
X25 a_24948_n500.t4 XGDAC.CTRL_A VSS.t101 VSS.t87 nfet_03v3 ad=2.6p pd=10.52u as=2.6p ps=10.52u w=10u l=0.28u
X26 a_n5852_53500.t0 XSEL.A_N.t9 a_n2796_53500.t4 VSS.t9 nfet_03v3 ad=1.3p pd=5.52u as=2.2p ps=10.88u w=5u l=0.28u
X27 VDD.t12 XSEL.A_P.t3 VSS.t4 ppolyf_u r_width=2u r_length=4u
X28 a_n31052_12300.t7 XFDAC.CTRL_A VSS.t174 VSS.t160 nfet_03v3 ad=6.6p pd=30.88u as=3.9p ps=15.52u w=15u l=0.28u
X29 a_1748_53500.t1 a_n2796_53500.t12 CLK_N.t1 VSS.t19 nfet_03v3 ad=1.3p pd=5.52u as=2.2p ps=10.88u w=5u l=0.28u
X30 VSS.t110 XFDAC.CTRL_B a_n28972_n400.t1 VSS.t109 nfet_03v3 ad=1.56p pd=6.52u as=2.64p ps=12.88u w=6u l=0.28u
X31 VDD.t11 a_n5996_53500.t0 VSS.t104 ppolyf_u r_width=2u r_length=4u
X32 VSS.t13 XSEL.B_N.t5 VSS.t12 VSS.t11 nfet_03v3 ad=1.76p pd=8.88u as=0 ps=0 w=4u l=3.45u
X33 a_24948_n500.t7 XGAIN.XBUF.INN.t5 XGAIN.XSTART.NODEN.t1 VSS.t33 nfet_03v3 ad=1.3p pd=5.52u as=2.2p ps=10.88u w=5u l=0.28u
X34 a_n16000_n37702.t4 F_B3B.t0 VREFL.t35 VSS.t216 nfet_03v3 ad=3.52p pd=16.88u as=2.08p ps=8.52u w=8u l=0.28u
X35 VDD.t9 CLK_N.t2 VSS.t74 ppolyf_u r_width=2u r_length=5.25u
X36 a_n40400_n37702.t1 F_A3B.t0 VREFL.t10 VSS.t65 nfet_03v3 ad=3.52p pd=16.88u as=2.08p ps=8.52u w=8u l=0.28u
X37 a_n31052_n500.t5 XFDAC.CTRL_A VSS.t175 VSS.t164 nfet_03v3 ad=3.9p pd=15.52u as=3.9p ps=15.52u w=15u l=0.28u
X38 XFDAC.CTRL_B a_n13000_n37702.t0 VSS.t25 ppolyf_u r_width=2u r_length=40u
X39 VREFH.t34 G_B0.t1 a_31000_n37702.t3 VSS.t212 nfet_03v3 ad=2.08p pd=8.52u as=3.52p ps=16.88u w=8u l=0.28u
X40 VDD.t4 XGAIN.XBUF.INN.t0 VSS.t11 ppolyf_u r_width=2u r_length=6.5u
X41 XGDAC.CTRL_A a_12600_n37702.t4 VSS.t156 ppolyf_u r_width=2u r_length=40u
X42 VREFH.t31 F_B3.t1 a_n16000_n37702.t1 VSS.t215 nfet_03v3 ad=2.08p pd=8.52u as=3.52p ps=16.88u w=8u l=0.28u
X43 VSS.t203 XGDAC.CTRL_B a_27028_25200.t2 VSS.t197 nfet_03v3 ad=1.04p pd=4.52u as=1.76p ps=8.88u w=4u l=0.28u
X44 VREFH.t1 F_A3.t1 a_n40400_n37702.t3 VSS.t64 nfet_03v3 ad=2.08p pd=8.52u as=3.52p ps=16.88u w=8u l=0.28u
X45 a_15600_n37702.t4 G_A3B.t0 VREFL.t38 VSS.t78 nfet_03v3 ad=3.52p pd=16.88u as=2.08p ps=8.52u w=8u l=0.28u
X46 VDD.t7 XGAIN.X2.INP.t2 VSS.t26 ppolyf_u r_width=2u r_length=6.5u
X47 XGAIN.XSTART.NODEN.t0 XGAIN.XBUF.INN.t4 a_24948_n500.t0 VSS.t20 nfet_03v3 ad=2.2p pd=10.88u as=1.3p ps=5.52u w=5u l=0.28u
X48 a_40000_n37702.t4 G_B3B.t0 VREFL.t40 VSS.t151 nfet_03v3 ad=3.52p pd=16.88u as=2.08p ps=8.52u w=8u l=0.28u
X49 a_n27200_n29600# a_n25000_n37702.t0 VSS.t3 ppolyf_u r_width=2u r_length=40u
X50 VREFH.t37 G_A2.t1 a_18600_n37702.t3 VSS.t152 nfet_03v3 ad=2.08p pd=8.52u as=3.52p ps=16.88u w=8u l=0.28u
X51 VREFH.t4 G_B4.t1 a_43000_n37702.t0 VSS.t79 nfet_03v3 ad=2.08p pd=8.52u as=3.52p ps=16.88u w=8u l=0.28u
X52 VSS.t167 XFDAC.CTRL_A a_n31052_37900.t4 VSS.t166 nfet_03v3 ad=3.9p pd=15.52u as=3.9p ps=15.52u w=15u l=0.28u
X53 a_23100_n28902# a_24600_n37702.t4 VSS.t238 ppolyf_u r_width=2u r_length=40u
X54 a_n38900_n28902# a_n35900_n28902# VSS.t105 ppolyf_u r_width=2u r_length=20u
X55 VSS.t131 XGAIN.X2.INN.t5 VSS.t130 VSS.t11 nfet_03v3 ad=1.76p pd=8.88u as=0 ps=0 w=4u l=3.45u
X56 VSS.t224 SEL_B.t1 a_n4252_53500.t9 VSS.t185 nfet_03v3 ad=1.3p pd=5.52u as=1.3p ps=5.52u w=5u l=0.28u
X57 a_n28972_25200.t0 XFAST.XBUF.INN.t6 XFAST.XBUF.INP.t3 VSS.t27 nfet_03v3 ad=1.76p pd=8.88u as=1.76p ps=8.88u w=4u l=0.28u
X58 VDD.t5 XFAST.X2.INP.t0 VSS.t4 ppolyf_u r_width=2u r_length=4u
X59 a_35500_n24800# a_32500_n24800# VSS.t41 ppolyf_u r_width=2u r_length=20u
X60 a_n13000_n37702.t2 F_B4.t0 VREFH.t29 VSS.t107 nfet_03v3 ad=3.52p pd=16.88u as=2.08p ps=8.52u w=8u l=0.28u
X61 VREFL.t8 G_A4B.t1 a_12600_n37702.t0 VSS.t57 nfet_03v3 ad=2.08p pd=8.52u as=3.52p ps=16.88u w=8u l=0.28u
X62 VREFL.t37 F_A2B.t1 a_n37400_n37702.t3 VSS.t124 nfet_03v3 ad=2.08p pd=8.52u as=3.52p ps=16.88u w=8u l=0.28u
X63 VSS.t32 XFAST.XSTART.NODEP.t6 VSS.t31 VSS.t4 nfet_03v3 ad=1.408p pd=7.28u as=0 ps=0 w=3.2u l=4.48u
X64 XFAST.XSTART.NODEP.t2 XFAST.XBUF.INP.t4 a_n31052_n500.t2 VSS.t23 nfet_03v3 ad=2.2p pd=10.88u as=1.3p ps=5.52u w=5u l=0.28u
X65 VREFL.t11 F_B1B.t1 a_n22000_n37702.t2 VSS.t28 nfet_03v3 ad=2.08p pd=8.52u as=3.52p ps=16.88u w=8u l=0.28u
X66 a_24948_25100.t3 XGDAC.CTRL_A VSS.t95 VSS.t87 nfet_03v3 ad=2.6p pd=10.52u as=2.6p ps=10.52u w=10u l=0.28u
X67 a_27028_n400.t0 XGAIN.XSTART.NODEN.t5 XGAIN.XSTART.NODEP.t3 VSS.t2 nfet_03v3 ad=1.76p pd=8.88u as=1.76p ps=8.88u w=4u l=0.28u
X68 a_n23500_n24800# a_n27200_n29600# VSS.t209 ppolyf_u r_width=2u r_length=20u
X69 VREFL.t0 G_A0B.t1 a_24600_n37702.t0 VSS.t0 nfet_03v3 ad=2.08p pd=8.52u as=3.52p ps=16.88u w=8u l=0.28u
X70 a_n25000_n37702.t2 F_B0.t0 VREFH.t28 VSS.t61 nfet_03v3 ad=3.52p pd=16.88u as=2.08p ps=8.52u w=8u l=0.28u
X71 a_n5852_53500.t2 XSEL.A_P.t9 a_n5996_53500.t1 VSS.t16 nfet_03v3 ad=1.3p pd=5.52u as=2.2p ps=10.88u w=5u l=0.28u
X72 a_1748_53500.t9 a_n2796_53500.t10 CLK_N.t4 VSS.t231 nfet_03v3 ad=1.3p pd=5.52u as=2.2p ps=10.88u w=5u l=0.28u
X73 XSEL.A_P.t1 XFAST.XBUF.INP.t8 a_n31052_37900.t1 VSS.t23 nfet_03v3 ad=2.2p pd=10.88u as=1.3p ps=5.52u w=5u l=0.28u
X74 a_24948_37900.t7 XGAIN.XBUF.INN.t9 XSEL.B_N.t1 VSS.t33 nfet_03v3 ad=1.3p pd=5.52u as=2.2p ps=10.88u w=5u l=0.28u
X75 a_n28972_25200.t3 XFAST.XBUF.INP.t6 XFAST.XBUF.INN.t1 VSS.t81 nfet_03v3 ad=1.76p pd=8.88u as=1.76p ps=8.88u w=4u l=0.28u
X76 a_12600_n37702.t3 G_A4.t0 VREFH.t7 VSS.t58 nfet_03v3 ad=3.52p pd=16.88u as=2.08p ps=8.52u w=8u l=0.28u
X77 a_20100_n28902# a_23100_n28902# VSS.t122 ppolyf_u r_width=2u r_length=20u
X78 a_n31052_25100.t3 XFDAC.CTRL_A VSS.t169 VSS.t164 nfet_03v3 ad=3.9p pd=15.52u as=3.9p ps=15.52u w=15u l=0.28u
X79 a_n31052_n500.t3 XFAST.XBUF.INP.t5 XFAST.XSTART.NODEP.t3 VSS.t30 nfet_03v3 ad=1.3p pd=5.52u as=2.2p ps=10.88u w=5u l=0.28u
X80 a_n34400_n37702.t4 F_A1B.t0 VREFL.t16 VSS.t63 nfet_03v3 ad=3.52p pd=16.88u as=2.08p ps=8.52u w=8u l=0.28u
X81 a_n31052_25100.t1 XFAST.X2.INP.t7 XFAST.XBUF.INP.t1 VSS.t30 nfet_03v3 ad=1.3p pd=5.52u as=2.2p ps=10.88u w=5u l=0.28u
X82 XGAIN.XBUF.INN.t3 XGAIN.X2.INN.t6 a_24948_25100.t6 VSS.t20 nfet_03v3 ad=2.2p pd=10.88u as=1.3p ps=5.52u w=5u l=0.28u
X83 a_24600_n37702.t3 G_A0.t0 VREFH.t10 VSS.t1 nfet_03v3 ad=3.52p pd=16.88u as=2.08p ps=8.52u w=8u l=0.28u
X84 a_n28972_n400.t2 XFDAC.CTRL_B VSS.t118 VSS.t113 nfet_03v3 ad=2.64p pd=12.88u as=1.56p ps=6.52u w=6u l=0.28u
X85 a_n5996_53500.t4 XSEL.A_P.t6 a_n5852_53500.t4 VSS.t46 nfet_03v3 ad=2.2p pd=10.88u as=1.3p ps=5.52u w=5u l=0.28u
X86 a_n2796_53500.t5 XSEL.A_N.t8 a_n5852_53500.t1 VSS.t10 nfet_03v3 ad=2.2p pd=10.88u as=1.3p ps=5.52u w=5u l=0.28u
X87 VSS.t138 XFAST.XBUF.INN.t7 VSS.t137 VSS.t5 nfet_03v3 ad=1.408p pd=7.28u as=0 ps=0 w=3.2u l=4.48u
X88 a_n31052_12300.t1 XFAST.XSTART.NODEN.t8 XFAST.X2.INN.t1 VSS.t34 nfet_03v3 ad=1.3p pd=5.52u as=2.2p ps=10.88u w=5u l=0.28u
X89 XGAIN.X2.INP.t1 XGAIN.XSTART.NODEP.t7 a_24948_12300.t2 VSS.t8 nfet_03v3 ad=2.2p pd=10.88u as=1.3p ps=5.52u w=5u l=0.28u
X90 VSS.t202 XGDAC.CTRL_B a_27028_12400.t2 VSS.t197 nfet_03v3 ad=1.04p pd=4.52u as=1.76p ps=8.88u w=4u l=0.28u
X91 a_n32900_n28902# a_n31400_n37702.t0 VSS.t47 ppolyf_u r_width=2u r_length=40u
X92 VSS.t225 SEL_B.t3 a_n4252_53500.t7 VSS.t181 nfet_03v3 ad=1.3p pd=5.52u as=2.2p ps=10.88u w=5u l=0.28u
X93 XFAST.XBUF.INN.t3 XFAST.X2.INN.t6 a_n31052_25100.t7 VSS.t22 nfet_03v3 ad=2.2p pd=10.88u as=1.3p ps=5.52u w=5u l=0.28u
X94 a_24948_25100.t1 XGAIN.X2.INP.t7 XGAIN.XBUF.INP.t2 VSS.t24 nfet_03v3 ad=1.3p pd=5.52u as=2.2p ps=10.88u w=5u l=0.28u
X95 a_27028_25200.t0 XGAIN.XBUF.INP.t6 XGAIN.XBUF.INN.t1 VSS.t21 nfet_03v3 ad=1.76p pd=8.88u as=1.76p ps=8.88u w=4u l=0.28u
X96 VSS.t176 XFDAC.CTRL_A a_n31052_n500.t6 VSS.t166 nfet_03v3 ad=3.9p pd=15.52u as=3.9p ps=15.52u w=15u l=0.28u
X97 a_n5852_53500.t7 SEL_A.t2 VSS.t184 VSS.t183 nfet_03v3 ad=1.3p pd=5.52u as=1.3p ps=5.52u w=5u l=0.28u
X98 a_34000_n37702.t1 G_B1B.t0 VREFL.t24 VSS.t155 nfet_03v3 ad=3.52p pd=16.88u as=2.08p ps=8.52u w=8u l=0.28u
X99 a_28800_n29600# a_31000_n37702.t0 VSS.t189 ppolyf_u r_width=2u r_length=40u
X100 VREFH.t26 F_A1.t1 a_n34400_n37702.t1 VSS.t62 nfet_03v3 ad=2.08p pd=8.52u as=3.52p ps=16.88u w=8u l=0.28u
X101 VDD.t13 a_n2796_53500.t8 VSS.t205 ppolyf_u r_width=2u r_length=4u
X102 a_n4252_53500.t5 XSEL.B_N.t7 a_n2796_53500.t2 VSS.t133 nfet_03v3 ad=1.3p pd=5.52u as=2.2p ps=10.88u w=5u l=0.28u
X103 VSS.t129 XGAIN.XSTART.NODEN.t6 VSS.t128 VSS.t11 nfet_03v3 ad=1.76p pd=8.88u as=0 ps=0 w=4u l=3.45u
X104 a_n20500_n24800# a_n19000_n37702.t4 VSS.t230 ppolyf_u r_width=2u r_length=40u
X105 VREFH.t12 G_B2.t1 a_37000_n37702.t0 VSS.t139 nfet_03v3 ad=2.08p pd=8.52u as=3.52p ps=16.88u w=8u l=0.28u
X106 VDD.t14 XSEL.B_N.t3 VSS.t11 ppolyf_u r_width=2u r_length=6.5u
X107 a_24948_12300.t6 XGDAC.CTRL_A VSS.t100 VSS.t92 nfet_03v3 ad=4.4p pd=20.88u as=2.6p ps=10.52u w=10u l=0.28u
X108 VDD.t16 XGAIN.XSTART.NODEN.t3 VSS.t11 ppolyf_u r_width=2u r_length=6.5u
X109 XFDAC.CTRL_A a_n43400_n37702.t2 VSS.t146 ppolyf_u r_width=2u r_length=40u
X110 a_n32900_n28902# VREFL.t26 VSS.t27 ppolyf_u r_width=2u r_length=40u
X111 a_1748_53500.t3 SEL_BUF.t2 VSS.t71 VSS.t70 nfet_03v3 ad=2.6p pd=10.52u as=2.6p ps=10.52u w=10u l=0.28u
X112 VREFH.t14 G_A1.t1 a_21600_n37702.t2 VSS.t39 nfet_03v3 ad=2.08p pd=8.52u as=3.52p ps=16.88u w=8u l=0.28u
X113 a_17100_n28902# a_18600_n37702.t2 VSS.t192 ppolyf_u r_width=2u r_length=40u
X114 a_27028_25200.t1 XGAIN.XBUF.INN.t6 XGAIN.XBUF.INP.t1 VSS.t2 nfet_03v3 ad=1.76p pd=8.88u as=1.76p ps=8.88u w=4u l=0.28u
X115 XGDAC.CTRL_B a_43000_n37702.t2 VSS.t157 ppolyf_u r_width=2u r_length=40u
X116 VSS.t179 FAST_KICKP.t0 XFAST.XSTART.NODEP.t4 VSS.t178 nfet_03v3 ad=0.44p pd=2.88u as=0.44p ps=2.88u w=1u l=0.28u
X117 VSS.t237 GAIN_KICKN.t0 XGAIN.XSTART.NODEN.t4 VSS.t236 nfet_03v3 ad=0.44p pd=2.88u as=0.44p ps=2.88u w=1u l=0.28u
X118 a_n31052_37900.t5 XFDAC.CTRL_A VSS.t161 VSS.t160 nfet_03v3 ad=6.6p pd=30.88u as=3.9p ps=15.52u w=15u l=0.28u
X119 a_n4252_53500.t10 SEL_B.t0 VSS.t227 VSS.t187 nfet_03v3 ad=2.2p pd=10.88u as=1.3p ps=5.52u w=5u l=0.28u
X120 VREFL.t33 G_B0B.t1 a_31000_n37702.t1 VSS.t212 nfet_03v3 ad=2.08p pd=8.52u as=3.52p ps=16.88u w=8u l=0.28u
X121 a_n31400_n37702.t4 F_A0.t0 VREFH.t32 VSS.t56 nfet_03v3 ad=3.52p pd=16.88u as=2.08p ps=8.52u w=8u l=0.28u
X122 a_27028_n400.t2 XGDAC.CTRL_B VSS.t204 VSS.t195 nfet_03v3 ad=1.76p pd=8.88u as=1.04p ps=4.52u w=4u l=0.28u
X123 VSS.t163 XFDAC.CTRL_A a_n31052_37900.t2 VSS.t158 nfet_03v3 ad=3.9p pd=15.52u as=6.6p ps=30.88u w=15u l=0.28u
X124 VREFL.t34 F_B3B.t1 a_n16000_n37702.t3 VSS.t215 nfet_03v3 ad=2.08p pd=8.52u as=3.52p ps=16.88u w=8u l=0.28u
X125 VSS.t85 XGDAC.CTRL_A a_24948_37900.t2 VSS.t84 nfet_03v3 ad=2.6p pd=10.52u as=4.4p ps=20.88u w=10u l=0.28u
X126 a_n17500_n24800# a_n20500_n24800# VSS.t222 ppolyf_u r_width=2u r_length=20u
X127 VREFL.t9 F_A3B.t1 a_n40400_n37702.t0 VSS.t64 nfet_03v3 ad=2.08p pd=8.52u as=3.52p ps=16.88u w=8u l=0.28u
X128 VREFL.t22 G_A2B.t1 a_18600_n37702.t0 VSS.t152 nfet_03v3 ad=2.08p pd=8.52u as=3.52p ps=16.88u w=8u l=0.28u
X129 a_n19000_n37702.t3 F_B2.t0 VREFH.t27 VSS.t76 nfet_03v3 ad=3.52p pd=16.88u as=2.08p ps=8.52u w=8u l=0.28u
X130 VDD.t10 XGAIN.X2.INN.t3 VSS.t11 ppolyf_u r_width=2u r_length=6.5u
X131 a_n43400_n37702.t4 F_A4.t0 VREFH.t0 VSS.t143 nfet_03v3 ad=3.52p pd=16.88u as=2.08p ps=8.52u w=8u l=0.28u
X132 VREFL.t30 G_B4B.t1 a_43000_n37702.t3 VSS.t79 nfet_03v3 ad=2.08p pd=8.52u as=3.52p ps=16.88u w=8u l=0.28u
X133 a_14100_n28902# a_17100_n28902# VSS.t136 ppolyf_u r_width=2u r_length=20u
X134 VDD.t17 XFAST.XSTART.NODEN.t4 VSS.t5 ppolyf_u r_width=2u r_length=4u
X135 a_31000_n37702.t4 G_B0.t0 VREFH.t33 VSS.t213 nfet_03v3 ad=3.52p pd=16.88u as=2.08p ps=8.52u w=8u l=0.28u
X136 a_24948_37900.t5 XGDAC.CTRL_A VSS.t93 VSS.t92 nfet_03v3 ad=4.4p pd=20.88u as=2.6p ps=10.52u w=10u l=0.28u
X137 a_n5996_53500.t2 XSEL.A_P.t8 a_n5852_53500.t3 VSS.t17 nfet_03v3 ad=2.2p pd=10.88u as=1.3p ps=5.52u w=5u l=0.28u
X138 VSS.t172 XFDAC.CTRL_A a_n31052_12300.t4 VSS.t158 nfet_03v3 ad=3.9p pd=15.52u as=6.6p ps=30.88u w=15u l=0.28u
X139 a_18600_n37702.t4 G_A2.t0 VREFH.t38 VSS.t153 nfet_03v3 ad=3.52p pd=16.88u as=2.08p ps=8.52u w=8u l=0.28u
X140 a_43000_n37702.t1 G_B4.t0 VREFH.t5 VSS.t80 nfet_03v3 ad=3.52p pd=16.88u as=2.08p ps=8.52u w=8u l=0.28u
X141 VSS.t112 XFDAC.CTRL_B a_n28972_38000.t1 VSS.t109 nfet_03v3 ad=1.56p pd=6.52u as=2.64p ps=12.88u w=6u l=0.28u
X142 VSS.t170 XFDAC.CTRL_A a_n31052_25100.t4 VSS.t166 nfet_03v3 ad=3.9p pd=15.52u as=3.9p ps=15.52u w=15u l=0.28u
X143 a_n13000_n37702.t4 F_B4B.t0 VREFL.t17 VSS.t107 nfet_03v3 ad=3.52p pd=16.88u as=2.08p ps=8.52u w=8u l=0.28u
X144 a_n4252_53500.t4 XSEL.B_N.t9 a_n2796_53500.t0 VSS.t132 nfet_03v3 ad=1.3p pd=5.52u as=2.2p ps=10.88u w=5u l=0.28u
X145 a_n31052_12300.t5 XFDAC.CTRL_A VSS.t168 VSS.t164 nfet_03v3 ad=3.9p pd=15.52u as=3.9p ps=15.52u w=15u l=0.28u
X146 a_n28972_12400.t0 XFAST.X2.INN.t4 XFAST.X2.INP.t3 VSS.t27 nfet_03v3 ad=1.76p pd=8.88u as=1.76p ps=8.88u w=4u l=0.28u
X147 a_n25000_n37702.t4 F_B0B.t0 VREFL.t29 VSS.t61 nfet_03v3 ad=3.52p pd=16.88u as=2.08p ps=8.52u w=8u l=0.28u
X148 VSS.t219 XSEL.A_N.t5 VSS.t218 VSS.t5 nfet_03v3 ad=1.408p pd=7.28u as=0 ps=0 w=3.2u l=4.48u
X149 a_n28972_n400.t3 XFAST.XSTART.NODEN.t5 XFAST.XSTART.NODEP.t1 VSS.t27 nfet_03v3 ad=1.76p pd=8.88u as=1.76p ps=8.88u w=4u l=0.28u
X150 a_12600_n37702.t1 G_A4B.t0 VREFL.t7 VSS.t58 nfet_03v3 ad=3.52p pd=16.88u as=2.08p ps=8.52u w=8u l=0.28u
X151 VREFH.t6 F_B4.t1 a_n13000_n37702.t1 VSS.t106 nfet_03v3 ad=2.08p pd=8.52u as=3.52p ps=16.88u w=8u l=0.28u
X152 VSS.t115 XFDAC.CTRL_B a_n28972_12400.t1 VSS.t109 nfet_03v3 ad=1.56p pd=6.52u as=2.64p ps=12.88u w=6u l=0.28u
X153 a_n31052_n500.t7 XFDAC.CTRL_A VSS.t177 VSS.t160 nfet_03v3 ad=6.6p pd=30.88u as=3.9p ps=15.52u w=15u l=0.28u
X154 a_n38900_n28902# a_n37400_n37702.t0 VSS.t123 ppolyf_u r_width=2u r_length=40u
X155 VREFH.t3 G_A3.t1 a_15600_n37702.t0 VSS.t77 nfet_03v3 ad=2.08p pd=8.52u as=3.52p ps=16.88u w=8u l=0.28u
X156 a_23100_n28902# VREFL.t27 VSS.t2 ppolyf_u r_width=2u r_length=40u
X157 VDD.t1 XFAST.XBUF.INN.t0 VSS.t5 ppolyf_u r_width=2u r_length=4u
X158 a_n23500_n24800# a_n22000_n37702.t4 VSS.t144 ppolyf_u r_width=2u r_length=40u
X159 VREFH.t20 G_B3.t1 a_40000_n37702.t0 VSS.t150 nfet_03v3 ad=2.08p pd=8.52u as=3.52p ps=16.88u w=8u l=0.28u
X160 a_35500_n24800# a_37000_n37702.t2 VSS.t223 ppolyf_u r_width=2u r_length=40u
X161 a_n2796_53500.t3 XSEL.B_N.t6 a_n4252_53500.t3 VSS.t121 nfet_03v3 ad=2.2p pd=10.88u as=1.3p ps=5.52u w=5u l=0.28u
X162 CLK_P.t0 a_n5996_53500.t11 a_1748_53500.t6 VSS.t108 nfet_03v3 ad=2.2p pd=10.88u as=1.3p ps=5.52u w=5u l=0.28u
X163 a_n28972_12400.t3 XFAST.X2.INP.t4 XFAST.X2.INN.t3 VSS.t81 nfet_03v3 ad=1.76p pd=8.88u as=1.76p ps=8.88u w=4u l=0.28u
X164 VSS.t162 XFDAC.CTRL_A a_n31052_n500.t4 VSS.t158 nfet_03v3 ad=3.9p pd=15.52u as=6.6p ps=30.88u w=15u l=0.28u
X165 a_24600_n37702.t1 G_A0B.t0 VREFL.t1 VSS.t1 nfet_03v3 ad=3.52p pd=16.88u as=2.08p ps=8.52u w=8u l=0.28u
X166 a_20100_n28902# a_21600_n37702.t4 VSS.t234 ppolyf_u r_width=2u r_length=40u
X167 VREFH.t24 F_B0.t1 a_n25000_n37702.t1 VSS.t60 nfet_03v3 ad=2.08p pd=8.52u as=3.52p ps=16.88u w=8u l=0.28u
X168 a_n35900_n28902# a_n32900_n28902# VSS.t141 ppolyf_u r_width=2u r_length=20u
X169 VSS.t49 XGAIN.XBUF.INP.t7 VSS.t48 VSS.t26 nfet_03v3 ad=1.76p pd=8.88u as=0 ps=0 w=4u l=3.45u
X170 a_32500_n24800# a_28800_n29600# VSS.t120 ppolyf_u r_width=2u r_length=20u
X171 VSS.t43 XFAST.XBUF.INP.t7 VSS.t42 VSS.t4 nfet_03v3 ad=1.408p pd=7.28u as=0 ps=0 w=3.2u l=4.48u
X172 a_n31052_12300.t2 XFAST.XSTART.NODEP.t8 XFAST.X2.INP.t1 VSS.t30 nfet_03v3 ad=1.3p pd=5.52u as=2.2p ps=10.88u w=5u l=0.28u
X173 XGAIN.X2.INN.t2 XGAIN.XSTART.NODEN.t7 a_24948_12300.t1 VSS.t20 nfet_03v3 ad=2.2p pd=10.88u as=1.3p ps=5.52u w=5u l=0.28u
X174 VREFL.t15 F_A1B.t1 a_n34400_n37702.t3 VSS.t62 nfet_03v3 ad=2.08p pd=8.52u as=3.52p ps=16.88u w=8u l=0.28u
X175 VSS.t97 XGDAC.CTRL_A a_24948_n500.t3 VSS.t84 nfet_03v3 ad=2.6p pd=10.52u as=4.4p ps=20.88u w=10u l=0.28u
X176 a_27028_38000.t3 XGDAC.CTRL_B VSS.t201 VSS.t195 nfet_03v3 ad=1.76p pd=8.88u as=1.04p ps=4.52u w=4u l=0.28u
X177 XFAST.XBUF.INP.t2 XFAST.X2.INP.t6 a_n31052_25100.t0 VSS.t23 nfet_03v3 ad=2.2p pd=10.88u as=1.3p ps=5.52u w=5u l=0.28u
X178 a_24948_25100.t7 XGAIN.X2.INN.t7 XGAIN.XBUF.INN.t2 VSS.t33 nfet_03v3 ad=1.3p pd=5.52u as=2.2p ps=10.88u w=5u l=0.28u
X179 VSS.t53 XFAST.X2.INN.t5 VSS.t52 VSS.t5 nfet_03v3 ad=1.408p pd=7.28u as=0 ps=0 w=3.2u l=4.48u
X180 VSS.t198 XGDAC.CTRL_B a_27028_n400.t1 VSS.t197 nfet_03v3 ad=1.04p pd=4.52u as=1.76p ps=8.88u w=4u l=0.28u
X181 VREFL.t42 G_B2B.t1 a_37000_n37702.t3 VSS.t139 nfet_03v3 ad=2.08p pd=8.52u as=3.52p ps=16.88u w=8u l=0.28u
X182 a_n37400_n37702.t2 F_A2.t0 VREFH.t17 VSS.t125 nfet_03v3 ad=3.52p pd=16.88u as=2.08p ps=8.52u w=8u l=0.28u
X183 a_n20500_n24800# a_n23500_n24800# VSS.t214 ppolyf_u r_width=2u r_length=20u
X184 XFAST.X2.INN.t2 XFAST.XSTART.NODEN.t7 a_n31052_12300.t0 VSS.t22 nfet_03v3 ad=2.2p pd=10.88u as=1.3p ps=5.52u w=5u l=0.28u
X185 a_24948_12300.t7 XGAIN.XSTART.NODEP.t8 XGAIN.X2.INP.t0 VSS.t24 nfet_03v3 ad=1.3p pd=5.52u as=2.2p ps=10.88u w=5u l=0.28u
X186 a_27028_12400.t1 XGAIN.X2.INP.t4 XGAIN.X2.INN.t0 VSS.t21 nfet_03v3 ad=1.76p pd=8.88u as=1.76p ps=8.88u w=4u l=0.28u
X187 VREFL.t3 G_A1B.t1 a_21600_n37702.t0 VSS.t39 nfet_03v3 ad=2.08p pd=8.52u as=3.52p ps=16.88u w=8u l=0.28u
X188 a_n22000_n37702.t1 F_B1.t0 VREFH.t22 VSS.t29 nfet_03v3 ad=3.52p pd=16.88u as=2.08p ps=8.52u w=8u l=0.28u
X189 a_n31052_37900.t6 XFAST.XBUF.INN.t9 XSEL.A_N.t1 VSS.t34 nfet_03v3 ad=1.3p pd=5.52u as=2.2p ps=10.88u w=5u l=0.28u
X190 XSEL.B_P.t3 XGAIN.XBUF.INP.t8 a_24948_37900.t0 VSS.t8 nfet_03v3 ad=2.2p pd=10.88u as=1.3p ps=5.52u w=5u l=0.28u
X191 VSS.t99 XGDAC.CTRL_A a_24948_12300.t5 VSS.t89 nfet_03v3 ad=2.6p pd=10.52u as=2.6p ps=10.52u w=10u l=0.28u
X192 a_24948_n500.t6 XGDAC.CTRL_A VSS.t103 VSS.t92 nfet_03v3 ad=4.4p pd=20.88u as=2.6p ps=10.52u w=10u l=0.28u
X193 a_17100_n28902# a_20100_n28902# VSS.t119 ppolyf_u r_width=2u r_length=20u
X194 VSS.t186 SEL_A.t1 a_n5852_53500.t8 VSS.t185 nfet_03v3 ad=1.3p pd=5.52u as=1.3p ps=5.52u w=5u l=0.28u
X195 VDD.t19 CLK_P.t4 VSS.t239 ppolyf_u r_width=2u r_length=5.25u
X196 a_n4252_53500.t1 XSEL.B_P.t7 a_n5996_53500.t7 VSS.t15 nfet_03v3 ad=1.3p pd=5.52u as=2.2p ps=10.88u w=5u l=0.28u
X197 VSS.t90 XGDAC.CTRL_A a_24948_37900.t4 VSS.t89 nfet_03v3 ad=2.6p pd=10.52u as=2.6p ps=10.52u w=10u l=0.28u
X198 a_37000_n37702.t1 G_B2.t0 VREFH.t11 VSS.t140 nfet_03v3 ad=3.52p pd=16.88u as=2.08p ps=8.52u w=8u l=0.28u
X199 a_27028_12400.t0 XGAIN.X2.INN.t4 XGAIN.X2.INP.t3 VSS.t2 nfet_03v3 ad=1.76p pd=8.88u as=1.76p ps=8.88u w=4u l=0.28u
X200 a_n31400_n37702.t2 F_A0B.t0 VREFL.t5 VSS.t56 nfet_03v3 ad=3.52p pd=16.88u as=2.08p ps=8.52u w=8u l=0.28u
X201 a_21600_n37702.t3 G_A1.t0 VREFH.t13 VSS.t40 nfet_03v3 ad=3.52p pd=16.88u as=2.08p ps=8.52u w=8u l=0.28u
X202 a_n31052_25100.t5 XFDAC.CTRL_A VSS.t171 VSS.t160 nfet_03v3 ad=6.6p pd=30.88u as=3.9p ps=15.52u w=15u l=0.28u
X203 a_n28972_38000.t2 XFDAC.CTRL_B VSS.t114 VSS.t113 nfet_03v3 ad=2.64p pd=12.88u as=1.56p ps=6.52u w=6u l=0.28u
X204 a_n28972_n400.t0 XFAST.XSTART.NODEP.t5 XFAST.XSTART.NODEN.t2 VSS.t81 nfet_03v3 ad=1.76p pd=8.88u as=1.76p ps=8.88u w=4u l=0.28u
X205 a_n19000_n37702.t1 F_B2B.t0 VREFL.t14 VSS.t76 nfet_03v3 ad=3.52p pd=16.88u as=2.08p ps=8.52u w=8u l=0.28u
X206 a_n2796_53500.t1 XSEL.B_N.t8 a_n4252_53500.t11 VSS.t229 nfet_03v3 ad=2.2p pd=10.88u as=1.3p ps=5.52u w=5u l=0.28u
X207 a_n43400_n37702.t1 F_A4B.t0 VREFL.t20 VSS.t143 nfet_03v3 ad=3.52p pd=16.88u as=2.08p ps=8.52u w=8u l=0.28u
X208 CLK_P.t1 a_n5996_53500.t9 a_1748_53500.t7 VSS.t127 nfet_03v3 ad=2.2p pd=10.88u as=1.3p ps=5.52u w=5u l=0.28u
X209 VSS.t159 XFDAC.CTRL_A a_n31052_25100.t2 VSS.t158 nfet_03v3 ad=3.9p pd=15.52u as=6.6p ps=30.88u w=15u l=0.28u
X210 a_31000_n37702.t2 G_B0B.t0 VREFL.t32 VSS.t213 nfet_03v3 ad=3.52p pd=16.88u as=2.08p ps=8.52u w=8u l=0.28u
X211 VREFH.t30 F_A0.t1 a_n31400_n37702.t3 VSS.t55 nfet_03v3 ad=2.08p pd=8.52u as=3.52p ps=16.88u w=8u l=0.28u
X212 a_n17500_n24800# a_n16000_n37702.t0 VSS.t126 ppolyf_u r_width=2u r_length=40u
X213 VREFH.t36 G_B1.t1 a_34000_n37702.t3 VSS.t154 nfet_03v3 ad=2.08p pd=8.52u as=3.52p ps=16.88u w=8u l=0.28u
X214 a_n41900_n28902# a_n40400_n37702.t2 VSS.t193 ppolyf_u r_width=2u r_length=40u
X215 VREFH.t18 F_B2.t1 a_n19000_n37702.t2 VSS.t75 nfet_03v3 ad=2.08p pd=8.52u as=3.52p ps=16.88u w=8u l=0.28u
X216 VREFH.t21 F_A4.t1 a_n43400_n37702.t3 VSS.t142 nfet_03v3 ad=2.08p pd=8.52u as=3.52p ps=16.88u w=8u l=0.28u
X217 a_18600_n37702.t1 G_A2B.t0 VREFL.t23 VSS.t153 nfet_03v3 ad=3.52p pd=16.88u as=2.08p ps=8.52u w=8u l=0.28u
X218 a_14100_n28902# a_15600_n37702.t2 VSS.t221 ppolyf_u r_width=2u r_length=40u
X219 a_24948_n500.t2 XGAIN.XBUF.INP.t5 XGAIN.XSTART.NODEP.t2 VSS.t24 nfet_03v3 ad=1.3p pd=5.52u as=2.2p ps=10.88u w=5u l=0.28u
X220 a_43000_n37702.t4 G_B4B.t0 VREFL.t31 VSS.t80 nfet_03v3 ad=3.52p pd=16.88u as=2.08p ps=8.52u w=8u l=0.28u
X221 a_38500_n24800# a_40000_n37702.t2 VSS.t208 ppolyf_u r_width=2u r_length=40u
X222 a_1748_53500.t11 a_n5996_53500.t12 CLK_P.t3 VSS.t235 nfet_03v3 ad=1.3p pd=5.52u as=2.2p ps=10.88u w=5u l=0.28u
X223 VDD.t15 XSEL.A_N.t3 VSS.t5 ppolyf_u r_width=2u r_length=4u
X224 VSS.t182 SEL_A.t3 a_n5852_53500.t6 VSS.t181 nfet_03v3 ad=1.3p pd=5.52u as=2.2p ps=10.88u w=5u l=0.28u
X225 VSS.t91 XGDAC.CTRL_A a_24948_25100.t2 VSS.t84 nfet_03v3 ad=2.6p pd=10.52u as=4.4p ps=20.88u w=10u l=0.28u
X226 VSS.t173 XFDAC.CTRL_A a_n31052_12300.t6 VSS.t166 nfet_03v3 ad=3.9p pd=15.52u as=3.9p ps=15.52u w=15u l=0.28u
X227 VDD.t3 XFAST.XSTART.NODEP.t0 VSS.t4 ppolyf_u r_width=2u r_length=4u
X228 VSS.t111 XFDAC.CTRL_B a_n28972_25200.t1 VSS.t109 nfet_03v3 ad=1.56p pd=6.52u as=2.64p ps=12.88u w=6u l=0.28u
X229 a_n41900_n28902# a_n38900_n28902# VSS.t194 ppolyf_u r_width=2u r_length=20u
X230 VREFL.t18 F_B4B.t1 a_n13000_n37702.t3 VSS.t106 nfet_03v3 ad=2.08p pd=8.52u as=3.52p ps=16.88u w=8u l=0.28u
X231 VSS.t51 XSEL.B_P.t5 VSS.t50 VSS.t26 nfet_03v3 ad=1.76p pd=8.88u as=0 ps=0 w=4u l=3.45u
X232 XGAIN.XSTART.NODEP.t1 XGAIN.XBUF.INP.t4 a_24948_n500.t1 VSS.t8 nfet_03v3 ad=2.2p pd=10.88u as=1.3p ps=5.52u w=5u l=0.28u
X233 XFDAC.CTRL_B a_n17500_n24800# VSS.t206 ppolyf_u r_width=2u r_length=20u
X234 a_38500_n24800# a_35500_n24800# VSS.t228 ppolyf_u r_width=2u r_length=20u
X235 a_n16000_n37702.t2 F_B3.t0 VREFH.t25 VSS.t216 nfet_03v3 ad=3.52p pd=16.88u as=2.08p ps=8.52u w=8u l=0.28u
X236 a_n4252_53500.t2 XSEL.B_P.t9 a_n5996_53500.t5 VSS.t45 nfet_03v3 ad=1.3p pd=5.52u as=2.2p ps=10.88u w=5u l=0.28u
X237 a_n5852_53500.t5 XSEL.A_N.t7 a_n2796_53500.t6 VSS.t145 nfet_03v3 ad=1.3p pd=5.52u as=2.2p ps=10.88u w=5u l=0.28u
X238 VSS.t135 XSEL.A_P.t5 VSS.t134 VSS.t4 nfet_03v3 ad=1.408p pd=7.28u as=0 ps=0 w=3.2u l=4.48u
X239 a_24948_25100.t5 XGDAC.CTRL_A VSS.t96 VSS.t92 nfet_03v3 ad=4.4p pd=20.88u as=2.6p ps=10.52u w=10u l=0.28u
X240 a_n28972_12400.t2 XFDAC.CTRL_B VSS.t117 VSS.t113 nfet_03v3 ad=2.64p pd=12.88u as=1.56p ps=6.52u w=6u l=0.28u
X241 a_n40400_n37702.t4 F_A3.t0 VREFH.t23 VSS.t65 nfet_03v3 ad=3.52p pd=16.88u as=2.08p ps=8.52u w=8u l=0.28u
X242 VREFL.t39 G_A3B.t1 a_15600_n37702.t3 VSS.t77 nfet_03v3 ad=2.08p pd=8.52u as=3.52p ps=16.88u w=8u l=0.28u
X243 a_1748_53500.t5 SEL_BUF.t0 VSS.t67 VSS.t66 nfet_03v3 ad=4.4p pd=20.88u as=2.6p ps=10.52u w=10u l=0.28u
X244 VSS.t200 XGDAC.CTRL_B a_27028_38000.t2 VSS.t197 nfet_03v3 ad=1.04p pd=4.52u as=1.76p ps=8.88u w=4u l=0.28u
X245 VREFL.t41 G_B3B.t1 a_40000_n37702.t3 VSS.t150 nfet_03v3 ad=2.08p pd=8.52u as=3.52p ps=16.88u w=8u l=0.28u
X246 XGDAC.CTRL_A a_14100_n28902# VSS.t54 ppolyf_u r_width=2u r_length=20u
X247 VDD.t2 XGAIN.XBUF.INP.t0 VSS.t26 ppolyf_u r_width=2u r_length=6.5u
X248 VREFL.t28 F_B0B.t1 a_n25000_n37702.t3 VSS.t60 nfet_03v3 ad=2.08p pd=8.52u as=3.52p ps=16.88u w=8u l=0.28u
X249 VDD.t0 XFAST.XBUF.INP.t0 VSS.t4 ppolyf_u r_width=2u r_length=4u
X250 VSS.t102 XGDAC.CTRL_A a_24948_n500.t5 VSS.t89 nfet_03v3 ad=2.6p pd=10.52u as=2.6p ps=10.52u w=10u l=0.28u
X251 a_15600_n37702.t1 G_A3.t0 VREFH.t2 VSS.t78 nfet_03v3 ad=3.52p pd=16.88u as=2.08p ps=8.52u w=8u l=0.28u
X252 a_n5852_53500.t9 SEL_A.t0 VSS.t188 VSS.t187 nfet_03v3 ad=2.2p pd=10.88u as=1.3p ps=5.52u w=5u l=0.28u
X253 a_n4252_53500.t8 SEL_B.t2 VSS.t226 VSS.t183 nfet_03v3 ad=1.3p pd=5.52u as=1.3p ps=5.52u w=5u l=0.28u
X254 a_40000_n37702.t1 G_B3.t0 VREFH.t19 VSS.t151 nfet_03v3 ad=3.52p pd=16.88u as=2.08p ps=8.52u w=8u l=0.28u
X255 a_n5996_53500.t8 XSEL.B_P.t6 a_n4252_53500.t6 VSS.t220 nfet_03v3 ad=2.2p pd=10.88u as=1.3p ps=5.52u w=5u l=0.28u
X256 CLK_N.t0 a_n2796_53500.t11 a_1748_53500.t0 VSS.t18 nfet_03v3 ad=2.2p pd=10.88u as=1.3p ps=5.52u w=5u l=0.28u
X257 a_24948_37900.t3 XGDAC.CTRL_A VSS.t88 VSS.t87 nfet_03v3 ad=2.6p pd=10.52u as=2.6p ps=10.52u w=10u l=0.28u
X258 VSS.t191 XGAIN.XBUF.INN.t7 VSS.t190 VSS.t11 nfet_03v3 ad=1.76p pd=8.88u as=0 ps=0 w=4u l=3.45u
X259 VSS.t36 XFAST.XSTART.NODEN.t6 VSS.t35 VSS.t5 nfet_03v3 ad=1.408p pd=7.28u as=0 ps=0 w=3.2u l=4.48u
X260 XFAST.XSTART.NODEN.t1 XFAST.XBUF.INN.t4 a_n31052_n500.t1 VSS.t22 nfet_03v3 ad=2.2p pd=10.88u as=1.3p ps=5.52u w=5u l=0.28u
X261 a_n28972_38000.t0 XSEL.A_N.t4 XSEL.A_P.t2 VSS.t27 nfet_03v3 ad=1.76p pd=8.88u as=1.76p ps=8.88u w=4u l=0.28u
X262 VSS.t38 XGAIN.X2.INP.t5 VSS.t37 VSS.t26 nfet_03v3 ad=1.76p pd=8.88u as=0 ps=0 w=4u l=3.45u
X263 a_n37400_n37702.t4 F_A2B.t0 VREFL.t36 VSS.t125 nfet_03v3 ad=3.52p pd=16.88u as=2.08p ps=8.52u w=8u l=0.28u
X264 VSS.t149 XFAST.X2.INP.t5 VSS.t148 VSS.t4 nfet_03v3 ad=1.408p pd=7.28u as=0 ps=0 w=3.2u l=4.48u
X265 a_n22000_n37702.t3 F_B1B.t0 VREFL.t12 VSS.t29 nfet_03v3 ad=3.52p pd=16.88u as=2.08p ps=8.52u w=8u l=0.28u
X266 VSS.t69 SEL_BUF.t3 a_1748_53500.t2 VSS.t68 nfet_03v3 ad=2.6p pd=10.52u as=4.4p ps=20.88u w=10u l=0.28u
X267 VDD.t8 XFAST.X2.INN.t0 VSS.t5 ppolyf_u r_width=2u r_length=4u
X268 XFAST.X2.INP.t2 XFAST.XSTART.NODEP.t7 a_n31052_12300.t3 VSS.t23 nfet_03v3 ad=2.2p pd=10.88u as=1.3p ps=5.52u w=5u l=0.28u
X269 a_n35900_n28902# a_n34400_n37702.t0 VSS.t59 ppolyf_u r_width=2u r_length=40u
X270 a_1748_53500.t10 a_n5996_53500.t10 CLK_P.t2 VSS.t233 nfet_03v3 ad=1.3p pd=5.52u as=2.2p ps=10.88u w=5u l=0.28u
X271 a_n31052_37900.t0 XFAST.XBUF.INP.t9 XSEL.A_P.t0 VSS.t30 nfet_03v3 ad=1.3p pd=5.52u as=2.2p ps=10.88u w=5u l=0.28u
X272 XSEL.B_N.t2 XGAIN.XBUF.INN.t8 a_24948_37900.t6 VSS.t20 nfet_03v3 ad=2.2p pd=10.88u as=1.3p ps=5.52u w=5u l=0.28u
X273 a_27028_25200.t3 XGDAC.CTRL_B VSS.t199 VSS.t195 nfet_03v3 ad=1.76p pd=8.88u as=1.04p ps=4.52u w=4u l=0.28u
X274 a_24948_12300.t0 XGAIN.XSTART.NODEN.t8 XGAIN.X2.INN.t1 VSS.t33 nfet_03v3 ad=1.3p pd=5.52u as=2.2p ps=10.88u w=5u l=0.28u
X275 a_24948_12300.t4 XGDAC.CTRL_A VSS.t98 VSS.t87 nfet_03v3 ad=2.6p pd=10.52u as=2.6p ps=10.52u w=10u l=0.28u
X276 VREFH.t8 G_A4.t1 a_12600_n37702.t2 VSS.t57 nfet_03v3 ad=2.08p pd=8.52u as=3.52p ps=16.88u w=8u l=0.28u
X277 a_n28972_38000.t3 XSEL.A_P.t4 XSEL.A_N.t0 VSS.t81 nfet_03v3 ad=1.76p pd=8.88u as=1.76p ps=8.88u w=4u l=0.28u
X278 a_n31052_n500.t0 XFAST.XBUF.INN.t5 XFAST.XSTART.NODEN.t0 VSS.t34 nfet_03v3 ad=1.3p pd=5.52u as=2.2p ps=10.88u w=5u l=0.28u
X279 a_37000_n37702.t4 G_B2B.t0 VREFL.t43 VSS.t140 nfet_03v3 ad=3.52p pd=16.88u as=2.08p ps=8.52u w=8u l=0.28u
X280 a_32500_n24800# a_34000_n37702.t2 VSS.t207 ppolyf_u r_width=2u r_length=40u
X281 VREFH.t39 F_A2.t1 a_n37400_n37702.t1 VSS.t124 nfet_03v3 ad=2.08p pd=8.52u as=3.52p ps=16.88u w=8u l=0.28u
X282 VSS.t83 FAST_KICKN.t0 XFAST.XSTART.NODEN.t3 VSS.t82 nfet_03v3 ad=0.44p pd=2.88u as=0.44p ps=2.88u w=1u l=0.28u
X283 VSS.t7 GAIN_KICKP.t0 XGAIN.XSTART.NODEP.t0 VSS.t6 nfet_03v3 ad=0.44p pd=2.88u as=0.44p ps=2.88u w=1u l=0.28u
X284 a_n27200_n29600# VREFL.t21 VSS.t81 ppolyf_u r_width=2u r_length=40u
X285 a_28800_n29600# VREFL.t2 VSS.t21 ppolyf_u r_width=2u r_length=40u
X286 a_21600_n37702.t1 G_A1B.t0 VREFL.t4 VSS.t40 nfet_03v3 ad=3.52p pd=16.88u as=2.08p ps=8.52u w=8u l=0.28u
X287 VREFH.t16 F_B1.t1 a_n22000_n37702.t0 VSS.t28 nfet_03v3 ad=2.08p pd=8.52u as=3.52p ps=16.88u w=8u l=0.28u
X288 XSEL.A_N.t2 XFAST.XBUF.INN.t8 a_n31052_37900.t7 VSS.t22 nfet_03v3 ad=2.2p pd=10.88u as=1.3p ps=5.52u w=5u l=0.28u
X289 a_n31052_37900.t3 XFDAC.CTRL_A VSS.t165 VSS.t164 nfet_03v3 ad=3.9p pd=15.52u as=3.9p ps=15.52u w=15u l=0.28u
X290 a_24948_37900.t1 XGAIN.XBUF.INP.t9 XSEL.B_P.t2 VSS.t24 nfet_03v3 ad=1.3p pd=5.52u as=2.2p ps=10.88u w=5u l=0.28u
X291 VSS.t86 XGDAC.CTRL_A a_24948_12300.t3 VSS.t84 nfet_03v3 ad=2.6p pd=10.52u as=4.4p ps=20.88u w=10u l=0.28u
R0 G_B4B.n0 G_B4B.t0 113.63
R1 G_B4B.n0 G_B4B.t1 113.603
R2 G_B4B G_B4B.n0 22.3237
R3 G_B3B.n0 G_B3B.t0 113.63
R4 G_B3B.n0 G_B3B.t1 113.603
R5 G_B3B G_B3B.n0 22.3237
R6 G_B2B.n0 G_B2B.t0 113.63
R7 G_B2B.n0 G_B2B.t1 113.603
R8 G_B2B G_B2B.n0 22.3237
R9 G_B1B.n0 G_B1B.t0 113.63
R10 G_B1B.n0 G_B1B.t1 113.603
R11 G_B1B G_B1B.n0 22.3237
R12 G_B0B.n0 G_B0B.t0 113.63
R13 G_B0B.n0 G_B0B.t1 113.603
R14 G_B0B G_B0B.n0 22.3237
R15 G_A0B.n0 G_A0B.t1 113.63
R16 G_A0B.n0 G_A0B.t0 113.603
R17 G_A0B G_A0B.n0 22.3237
R18 G_A1B.n0 G_A1B.t1 113.63
R19 G_A1B.n0 G_A1B.t0 113.603
R20 G_A1B G_A1B.n0 22.3237
R21 G_A2B.n0 G_A2B.t1 113.63
R22 G_A2B.n0 G_A2B.t0 113.603
R23 G_A2B G_A2B.n0 22.3237
R24 G_A3B.n0 G_A3B.t1 113.63
R25 G_A3B.n0 G_A3B.t0 113.603
R26 G_A3B G_A3B.n0 22.3237
R27 G_A4B.n0 G_A4B.t1 113.63
R28 G_A4B.n0 G_A4B.t0 113.603
R29 G_A4B G_A4B.n0 22.3237
R30 G_B4.n0 G_B4.t1 113.63
R31 G_B4.n0 G_B4.t0 113.603
R32 G_B4 G_B4.n0 26.5259
R33 G_B3.n0 G_B3.t1 113.63
R34 G_B3.n0 G_B3.t0 113.603
R35 G_B3 G_B3.n0 26.5259
R36 G_B2.n0 G_B2.t1 113.63
R37 G_B2.n0 G_B2.t0 113.603
R38 G_B2 G_B2.n0 26.5259
R39 G_B1.n0 G_B1.t1 113.63
R40 G_B1.n0 G_B1.t0 113.603
R41 G_B1 G_B1.n0 26.5259
R42 G_B0.n0 G_B0.t1 113.63
R43 G_B0.n0 G_B0.t0 113.603
R44 G_B0 G_B0.n0 26.5259
R45 G_A0.n0 G_A0.t0 113.63
R46 G_A0.n0 G_A0.t1 113.603
R47 G_A0 G_A0.n0 26.5259
R48 G_A1.n0 G_A1.t0 113.63
R49 G_A1.n0 G_A1.t1 113.603
R50 G_A1 G_A1.n0 26.5259
R51 G_A2.n0 G_A2.t0 113.63
R52 G_A2.n0 G_A2.t1 113.603
R53 G_A2 G_A2.n0 26.5259
R54 G_A3.n0 G_A3.t0 113.63
R55 G_A3.n0 G_A3.t1 113.603
R56 G_A3 G_A3.n0 26.5259
R57 G_A4.n0 G_A4.t0 113.63
R58 G_A4.n0 G_A4.t1 113.603
R59 G_A4 G_A4.n0 26.5259
R60 F_B4B.n0 F_B4B.t0 113.63
R61 F_B4B.n0 F_B4B.t1 113.603
R62 F_B4B F_B4B.n0 22.3237
R63 F_B3B.n0 F_B3B.t0 113.63
R64 F_B3B.n0 F_B3B.t1 113.603
R65 F_B3B F_B3B.n0 22.3237
R66 F_B2B.n0 F_B2B.t0 113.63
R67 F_B2B.n0 F_B2B.t1 113.603
R68 F_B2B F_B2B.n0 22.3237
R69 F_B1B.n0 F_B1B.t0 113.63
R70 F_B1B.n0 F_B1B.t1 113.603
R71 F_B1B F_B1B.n0 22.3237
R72 F_B0B.n0 F_B0B.t0 113.63
R73 F_B0B.n0 F_B0B.t1 113.603
R74 F_B0B F_B0B.n0 22.3237
R75 F_A0B.n0 F_A0B.t1 113.63
R76 F_A0B.n0 F_A0B.t0 113.603
R77 F_A0B F_A0B.n0 22.3237
R78 F_A1B.n0 F_A1B.t1 113.63
R79 F_A1B.n0 F_A1B.t0 113.603
R80 F_A1B F_A1B.n0 22.3237
R81 F_A2B.n0 F_A2B.t1 113.63
R82 F_A2B.n0 F_A2B.t0 113.603
R83 F_A2B F_A2B.n0 22.3237
R84 F_A3B.n0 F_A3B.t1 113.63
R85 F_A3B.n0 F_A3B.t0 113.603
R86 F_A3B F_A3B.n0 22.3237
R87 F_A4B.n0 F_A4B.t1 113.63
R88 F_A4B.n0 F_A4B.t0 113.603
R89 F_A4B F_A4B.n0 22.3237
R90 VREFH.n2 VREFH.n0 11.9554
R91 VREFH.n21 VREFH.n19 11.9554
R92 VREFH.n2 VREFH.n1 10.1791
R93 VREFH.n4 VREFH.n3 10.1791
R94 VREFH.n6 VREFH.n5 10.1791
R95 VREFH.n8 VREFH.n7 10.1791
R96 VREFH.n10 VREFH.n9 10.1791
R97 VREFH.n12 VREFH.n11 10.1791
R98 VREFH.n14 VREFH.n13 10.1791
R99 VREFH.n16 VREFH.n15 10.1791
R100 VREFH.n18 VREFH.n17 10.1791
R101 VREFH.n37 VREFH.n36 10.1791
R102 VREFH.n35 VREFH.n34 10.1791
R103 VREFH.n33 VREFH.n32 10.1791
R104 VREFH.n31 VREFH.n30 10.1791
R105 VREFH.n29 VREFH.n28 10.1791
R106 VREFH.n27 VREFH.n26 10.1791
R107 VREFH.n25 VREFH.n24 10.1791
R108 VREFH.n23 VREFH.n22 10.1791
R109 VREFH.n21 VREFH.n20 10.1791
R110 VREFH VREFH.n18 8.17155
R111 VREFH VREFH.n37 6.98734
R112 VREFH.n29 VREFH.n27 3.78997
R113 VREFH.n10 VREFH.n8 3.78997
R114 VREFH.n23 VREFH.n21 1.77682
R115 VREFH.n25 VREFH.n23 1.77682
R116 VREFH.n27 VREFH.n25 1.77682
R117 VREFH.n31 VREFH.n29 1.77682
R118 VREFH.n33 VREFH.n31 1.77682
R119 VREFH.n35 VREFH.n33 1.77682
R120 VREFH.n37 VREFH.n35 1.77682
R121 VREFH.n18 VREFH.n16 1.77682
R122 VREFH.n16 VREFH.n14 1.77682
R123 VREFH.n14 VREFH.n12 1.77682
R124 VREFH.n12 VREFH.n10 1.77682
R125 VREFH.n8 VREFH.n6 1.77682
R126 VREFH.n6 VREFH.n4 1.77682
R127 VREFH.n4 VREFH.n2 1.77682
R128 VREFH.n0 VREFH.t4 0.20525
R129 VREFH.n0 VREFH.t5 0.20525
R130 VREFH.n1 VREFH.t20 0.20525
R131 VREFH.n1 VREFH.t19 0.20525
R132 VREFH.n3 VREFH.t12 0.20525
R133 VREFH.n3 VREFH.t11 0.20525
R134 VREFH.n5 VREFH.t36 0.20525
R135 VREFH.n5 VREFH.t35 0.20525
R136 VREFH.n7 VREFH.t34 0.20525
R137 VREFH.n7 VREFH.t33 0.20525
R138 VREFH.n9 VREFH.t9 0.20525
R139 VREFH.n9 VREFH.t10 0.20525
R140 VREFH.n11 VREFH.t14 0.20525
R141 VREFH.n11 VREFH.t13 0.20525
R142 VREFH.n13 VREFH.t37 0.20525
R143 VREFH.n13 VREFH.t38 0.20525
R144 VREFH.n15 VREFH.t3 0.20525
R145 VREFH.n15 VREFH.t2 0.20525
R146 VREFH.n17 VREFH.t8 0.20525
R147 VREFH.n17 VREFH.t7 0.20525
R148 VREFH.n36 VREFH.t6 0.20525
R149 VREFH.n36 VREFH.t29 0.20525
R150 VREFH.n34 VREFH.t31 0.20525
R151 VREFH.n34 VREFH.t25 0.20525
R152 VREFH.n32 VREFH.t18 0.20525
R153 VREFH.n32 VREFH.t27 0.20525
R154 VREFH.n30 VREFH.t16 0.20525
R155 VREFH.n30 VREFH.t22 0.20525
R156 VREFH.n28 VREFH.t24 0.20525
R157 VREFH.n28 VREFH.t28 0.20525
R158 VREFH.n26 VREFH.t30 0.20525
R159 VREFH.n26 VREFH.t32 0.20525
R160 VREFH.n24 VREFH.t26 0.20525
R161 VREFH.n24 VREFH.t15 0.20525
R162 VREFH.n22 VREFH.t39 0.20525
R163 VREFH.n22 VREFH.t17 0.20525
R164 VREFH.n20 VREFH.t1 0.20525
R165 VREFH.n20 VREFH.t23 0.20525
R166 VREFH.n19 VREFH.t21 0.20525
R167 VREFH.n19 VREFH.t0 0.20525
R168 F_B4.n0 F_B4.t1 113.63
R169 F_B4.n0 F_B4.t0 113.603
R170 F_B4 F_B4.n0 26.5259
R171 F_B3.n0 F_B3.t1 113.63
R172 F_B3.n0 F_B3.t0 113.603
R173 F_B3 F_B3.n0 26.5259
R174 F_B2.n0 F_B2.t1 113.63
R175 F_B2.n0 F_B2.t0 113.603
R176 F_B2 F_B2.n0 26.5259
R177 F_B1.n0 F_B1.t1 113.63
R178 F_B1.n0 F_B1.t0 113.603
R179 F_B1 F_B1.n0 26.5259
R180 F_B0.n0 F_B0.t1 113.63
R181 F_B0.n0 F_B0.t0 113.603
R182 F_B0 F_B0.n0 26.5259
R183 F_A0.n0 F_A0.t0 113.63
R184 F_A0.n0 F_A0.t1 113.603
R185 F_A0 F_A0.n0 26.5259
R186 F_A1.n0 F_A1.t0 113.63
R187 F_A1.n0 F_A1.t1 113.603
R188 F_A1 F_A1.n0 26.5259
R189 F_A2.n0 F_A2.t0 113.63
R190 F_A2.n0 F_A2.t1 113.603
R191 F_A2 F_A2.n0 26.5259
R192 F_A3.n0 F_A3.t0 113.63
R193 F_A3.n0 F_A3.t1 113.603
R194 F_A3 F_A3.n0 26.5259
R195 F_A4.n0 F_A4.t0 113.63
R196 F_A4.n0 F_A4.t1 113.603
R197 F_A4 F_A4.n0 26.5259
R198 VREFL.n30 VREFL.t26 32.3061
R199 VREFL.n31 VREFL.t21 32.3061
R200 VREFL.n10 VREFL.t27 32.3061
R201 VREFL.n9 VREFL.t2 32.3061
R202 VREFL.n2 VREFL.n0 11.9554
R203 VREFL.n23 VREFL.n21 11.9554
R204 VREFL.n2 VREFL.n1 10.1791
R205 VREFL.n4 VREFL.n3 10.1791
R206 VREFL.n6 VREFL.n5 10.1791
R207 VREFL.n8 VREFL.n7 10.1791
R208 VREFL.n12 VREFL.n11 10.1791
R209 VREFL.n14 VREFL.n13 10.1791
R210 VREFL.n16 VREFL.n15 10.1791
R211 VREFL.n18 VREFL.n17 10.1791
R212 VREFL.n20 VREFL.n19 10.1791
R213 VREFL.n41 VREFL.n40 10.1791
R214 VREFL.n39 VREFL.n38 10.1791
R215 VREFL.n37 VREFL.n36 10.1791
R216 VREFL.n35 VREFL.n34 10.1791
R217 VREFL.n33 VREFL.n32 10.1791
R218 VREFL.n29 VREFL.n28 10.1791
R219 VREFL.n27 VREFL.n26 10.1791
R220 VREFL.n25 VREFL.n24 10.1791
R221 VREFL.n23 VREFL.n22 10.1791
R222 VREFL VREFL.n20 8.17155
R223 VREFL VREFL.n41 6.98734
R224 VREFL.n25 VREFL.n23 1.77682
R225 VREFL.n27 VREFL.n25 1.77682
R226 VREFL.n29 VREFL.n27 1.77682
R227 VREFL.n35 VREFL.n33 1.77682
R228 VREFL.n37 VREFL.n35 1.77682
R229 VREFL.n39 VREFL.n37 1.77682
R230 VREFL.n41 VREFL.n39 1.77682
R231 VREFL.n20 VREFL.n18 1.77682
R232 VREFL.n18 VREFL.n16 1.77682
R233 VREFL.n16 VREFL.n14 1.77682
R234 VREFL.n14 VREFL.n12 1.77682
R235 VREFL.n8 VREFL.n6 1.77682
R236 VREFL.n6 VREFL.n4 1.77682
R237 VREFL.n4 VREFL.n2 1.77682
R238 VREFL.n30 VREFL.n29 1.30313
R239 VREFL.n33 VREFL.n31 1.30313
R240 VREFL.n12 VREFL.n10 1.30313
R241 VREFL.n9 VREFL.n8 1.30313
R242 VREFL.n31 VREFL.n30 1.18471
R243 VREFL.n10 VREFL.n9 1.18471
R244 VREFL.n0 VREFL.t30 0.20525
R245 VREFL.n0 VREFL.t31 0.20525
R246 VREFL.n1 VREFL.t41 0.20525
R247 VREFL.n1 VREFL.t40 0.20525
R248 VREFL.n3 VREFL.t42 0.20525
R249 VREFL.n3 VREFL.t43 0.20525
R250 VREFL.n5 VREFL.t25 0.20525
R251 VREFL.n5 VREFL.t24 0.20525
R252 VREFL.n7 VREFL.t33 0.20525
R253 VREFL.n7 VREFL.t32 0.20525
R254 VREFL.n11 VREFL.t0 0.20525
R255 VREFL.n11 VREFL.t1 0.20525
R256 VREFL.n13 VREFL.t3 0.20525
R257 VREFL.n13 VREFL.t4 0.20525
R258 VREFL.n15 VREFL.t22 0.20525
R259 VREFL.n15 VREFL.t23 0.20525
R260 VREFL.n17 VREFL.t39 0.20525
R261 VREFL.n17 VREFL.t38 0.20525
R262 VREFL.n19 VREFL.t8 0.20525
R263 VREFL.n19 VREFL.t7 0.20525
R264 VREFL.n40 VREFL.t18 0.20525
R265 VREFL.n40 VREFL.t17 0.20525
R266 VREFL.n38 VREFL.t34 0.20525
R267 VREFL.n38 VREFL.t35 0.20525
R268 VREFL.n36 VREFL.t13 0.20525
R269 VREFL.n36 VREFL.t14 0.20525
R270 VREFL.n34 VREFL.t11 0.20525
R271 VREFL.n34 VREFL.t12 0.20525
R272 VREFL.n32 VREFL.t28 0.20525
R273 VREFL.n32 VREFL.t29 0.20525
R274 VREFL.n28 VREFL.t6 0.20525
R275 VREFL.n28 VREFL.t5 0.20525
R276 VREFL.n26 VREFL.t15 0.20525
R277 VREFL.n26 VREFL.t16 0.20525
R278 VREFL.n24 VREFL.t37 0.20525
R279 VREFL.n24 VREFL.t36 0.20525
R280 VREFL.n22 VREFL.t9 0.20525
R281 VREFL.n22 VREFL.t10 0.20525
R282 VREFL.n21 VREFL.t19 0.20525
R283 VREFL.n21 VREFL.t20 0.20525
R284 GAIN_KICKN GAIN_KICKN.t0 78.5823
R285 GAIN_KICKP GAIN_KICKP.t0 78.5823
R286 FAST_KICKN FAST_KICKN.t0 78.5823
R287 FAST_KICKP FAST_KICKP.t0 78.5823
R288 SEL_B.n0 SEL_B.t0 74.5242
R289 SEL_B.n3 SEL_B.t3 74.5242
R290 SEL_B.n1 SEL_B.t1 70.0675
R291 SEL_B.n2 SEL_B.t2 70.0675
R292 SEL_B SEL_B.n4 18.2966
R293 SEL_B.n2 SEL_B.n1 11.6805
R294 SEL_B.n4 SEL_B.n0 7.10487
R295 SEL_B.n4 SEL_B.n3 7.10487
R296 SEL_B.n1 SEL_B.n0 4.42851
R297 SEL_B.n3 SEL_B.n2 4.42851
R298 SEL_A.n0 SEL_A.t0 74.5242
R299 SEL_A.n3 SEL_A.t3 74.5242
R300 SEL_A.n1 SEL_A.t1 70.0675
R301 SEL_A.n2 SEL_A.t2 70.0675
R302 SEL_A SEL_A.n4 16.6979
R303 SEL_A.n2 SEL_A.n1 11.6805
R304 SEL_A.n4 SEL_A.n0 7.10487
R305 SEL_A.n4 SEL_A.n3 7.10487
R306 SEL_A.n1 SEL_A.n0 4.42851
R307 SEL_A.n3 SEL_A.n2 4.42851
R308 SEL_BUF.n0 SEL_BUF.t0 139.702
R309 SEL_BUF.n3 SEL_BUF.t3 139.702
R310 SEL_BUF.n1 SEL_BUF.t1 135.246
R311 SEL_BUF.n2 SEL_BUF.t2 135.246
R312 SEL_BUF SEL_BUF.n4 14.7439
R313 SEL_BUF.n2 SEL_BUF.n1 11.6805
R314 SEL_BUF.n4 SEL_BUF.n0 7.10487
R315 SEL_BUF.n4 SEL_BUF.n3 7.10487
R316 SEL_BUF.n1 SEL_BUF.n0 4.42851
R317 SEL_BUF.n3 SEL_BUF.n2 4.42851
R318 CLK_N CLK_N.t2 12.5251
R319 CLK_N.n1 CLK_N.t1 6.0676
R320 CLK_N.n0 CLK_N.t3 6.06663
R321 CLK_N.n0 CLK_N.t4 6.0653
R322 CLK_N.n1 CLK_N.t0 6.06436
R323 CLK_N.n2 CLK_N.n1 2.46891
R324 CLK_N.n2 CLK_N.n0 2.22074
R325 CLK_N CLK_N.n2 0.982318
R326 CLK_P CLK_P.t4 12.5251
R327 CLK_P.n0 CLK_P.t1 6.0676
R328 CLK_P.n1 CLK_P.t3 6.06663
R329 CLK_P.n1 CLK_P.t0 6.0653
R330 CLK_P.n0 CLK_P.t2 6.06436
R331 CLK_P.n2 CLK_P.n0 2.46891
R332 CLK_P.n2 CLK_P.n1 2.22074
R333 CLK_P CLK_P.n2 0.982318
R334 VDD VDD.n6 23.3752
R335 VDD.n8 VDD.t11 22.412
R336 VDD.n7 VDD.t9 21.9835
R337 VDD.n17 VDD.n16 21.6384
R338 VDD.n8 VDD.t13 21.612
R339 VDD.n7 VDD.t19 21.5835
R340 VDD.n15 VDD.t16 21.4659
R341 VDD.n15 VDD.t18 21.4659
R342 VDD.n12 VDD.t4 21.4659
R343 VDD.n12 VDD.t2 21.4659
R344 VDD.n11 VDD.t14 21.4659
R345 VDD.n11 VDD.t6 21.4659
R346 VDD.n10 VDD.t10 21.4659
R347 VDD.n10 VDD.t7 21.4659
R348 VDD.n5 VDD.t17 21.4659
R349 VDD.n5 VDD.t3 21.4659
R350 VDD.n2 VDD.t1 21.4659
R351 VDD.n2 VDD.t0 21.4659
R352 VDD.n1 VDD.t15 21.4659
R353 VDD.n1 VDD.t12 21.4659
R354 VDD.n0 VDD.t8 21.4659
R355 VDD.n0 VDD.t5 21.4659
R356 VDD.n13 VDD.n11 16.9789
R357 VDD.n3 VDD.n1 16.9789
R358 VDD.n16 VDD.n15 16.9331
R359 VDD.n6 VDD.n5 16.9331
R360 VDD.n13 VDD.n12 9.48997
R361 VDD.n3 VDD.n2 9.48997
R362 VDD.n14 VDD.n10 9.43668
R363 VDD.n4 VDD.n0 9.43668
R364 VDD.n14 VDD.n13 7.48471
R365 VDD.n4 VDD.n3 7.48471
R366 VDD VDD.n17 2.18179
R367 VDD.n17 VDD.n9 1.04366
R368 VDD.n9 VDD.n7 0.7505
R369 VDD.n9 VDD.n8 0.1505
R370 VDD.n16 VDD.n14 0.0305
R371 VDD.n6 VDD.n4 0.0305
R372 VSS.n1176 VSS.n1124 151.243
R373 VSS.n1076 VSS.n379 111.739
R374 VSS.n1181 VSS.n343 70.0005
R375 VSS.n1181 VSS.n341 70.0005
R376 VSS.n1185 VSS.n341 70.0005
R377 VSS.n1185 VSS.n332 70.0005
R378 VSS.n1192 VSS.n332 70.0005
R379 VSS.n1192 VSS.n329 70.0005
R380 VSS.n1196 VSS.n329 70.0005
R381 VSS.n1196 VSS.n189 70.0005
R382 VSS.n1204 VSS.n189 70.0005
R383 VSS.n1205 VSS.n1204 70.0005
R384 VSS.n1205 VSS.n234 70.0005
R385 VSS.n1209 VSS.n234 70.0005
R386 VSS.n1209 VSS.n297 70.0005
R387 VSS.n306 VSS.n297 70.0005
R388 VSS.n306 VSS.n304 70.0005
R389 VSS.n310 VSS.n304 70.0005
R390 VSS.n310 VSS.n303 70.0005
R391 VSS.n303 VSS.n50 70.0005
R392 VSS.n1430 VSS.n50 70.0005
R393 VSS.n1430 VSS.n9 70.0005
R394 VSS.n22 VSS.n21 70.0005
R395 VSS.n26 VSS.n17 70.0005
R396 VSS.n29 VSS.n28 70.0005
R397 VSS.n33 VSS.n14 70.0005
R398 VSS.n36 VSS.n35 70.0005
R399 VSS.n38 VSS.n11 70.0005
R400 VSS.n42 VSS.n11 70.0005
R401 VSS.n46 VSS.n44 70.0005
R402 VSS.n346 VSS.n345 70.0005
R403 VSS.n1139 VSS.n345 70.0005
R404 VSS.n1139 VSS.n339 70.0005
R405 VSS.n339 VSS.n338 70.0005
R406 VSS.n338 VSS.n337 70.0005
R407 VSS.n337 VSS.n328 70.0005
R408 VSS.n1198 VSS.n328 70.0005
R409 VSS.n1198 VSS.n187 70.0005
R410 VSS.n1202 VSS.n187 70.0005
R411 VSS.n1202 VSS.n301 70.0005
R412 VSS.n301 VSS.n233 70.0005
R413 VSS.n296 VSS.n233 70.0005
R414 VSS.n322 VSS.n296 70.0005
R415 VSS.n322 VSS.n320 70.0005
R416 VSS.n320 VSS.n319 70.0005
R417 VSS.n319 VSS.n311 70.0005
R418 VSS.n315 VSS.n311 70.0005
R419 VSS.n315 VSS.n314 70.0005
R420 VSS.n314 VSS.n54 70.0005
R421 VSS.n54 VSS.n5 70.0005
R422 VSS.n1147 VSS.n1146 70.0005
R423 VSS.n1151 VSS.n1150 70.0005
R424 VSS.n1155 VSS.n1154 70.0005
R425 VSS.n1159 VSS.n1158 70.0005
R426 VSS.n1163 VSS.n1162 70.0005
R427 VSS.n1167 VSS.n1166 70.0005
R428 VSS.n1171 VSS.n1170 70.0005
R429 VSS.n1175 VSS.n1133 70.0005
R430 VSS.n874 VSS.n821 70.0005
R431 VSS.n874 VSS.n813 70.0005
R432 VSS.n881 VSS.n813 70.0005
R433 VSS.n881 VSS.n811 70.0005
R434 VSS.n885 VSS.n811 70.0005
R435 VSS.n885 VSS.n691 70.0005
R436 VSS.n893 VSS.n691 70.0005
R437 VSS.n893 VSS.n471 70.0005
R438 VSS.n688 VSS.n471 70.0005
R439 VSS.n898 VSS.n688 70.0005
R440 VSS.n898 VSS.n497 70.0005
R441 VSS.n795 VSS.n497 70.0005
R442 VSS.n795 VSS.n698 70.0005
R443 VSS.n791 VSS.n698 70.0005
R444 VSS.n791 VSS.n700 70.0005
R445 VSS.n784 VSS.n700 70.0005
R446 VSS.n784 VSS.n704 70.0005
R447 VSS.n780 VSS.n704 70.0005
R448 VSS.n780 VSS.n706 70.0005
R449 VSS.n762 VSS.n706 70.0005
R450 VSS.n734 VSS.n727 70.0005
R451 VSS.n737 VSS.n736 70.0005
R452 VSS.n741 VSS.n724 70.0005
R453 VSS.n742 VSS.n741 70.0005
R454 VSS.n744 VSS.n722 70.0005
R455 VSS.n748 VSS.n722 70.0005
R456 VSS.n751 VSS.n750 70.0005
R457 VSS.n755 VSS.n719 70.0005
R458 VSS.n756 VSS.n755 70.0005
R459 VSS.n838 VSS.n819 70.0005
R460 VSS.n819 VSS.n818 70.0005
R461 VSS.n818 VSS.n817 70.0005
R462 VSS.n817 VSS.n805 70.0005
R463 VSS.n887 VSS.n805 70.0005
R464 VSS.n887 VSS.n692 70.0005
R465 VSS.n891 VSS.n692 70.0005
R466 VSS.n891 VSS.n469 70.0005
R467 VSS.n801 VSS.n469 70.0005
R468 VSS.n801 VSS.n687 70.0005
R469 VSS.n687 VSS.n496 70.0005
R470 VSS.n797 VSS.n496 70.0005
R471 VSS.n797 VSS.n694 70.0005
R472 VSS.n789 VSS.n694 70.0005
R473 VSS.n789 VSS.n701 70.0005
R474 VSS.n785 VSS.n701 70.0005
R475 VSS.n785 VSS.n703 70.0005
R476 VSS.n768 VSS.n703 70.0005
R477 VSS.n768 VSS.n708 70.0005
R478 VSS.n764 VSS.n708 70.0005
R479 VSS.n843 VSS.n842 70.0005
R480 VSS.n847 VSS.n846 70.0005
R481 VSS.n851 VSS.n850 70.0005
R482 VSS.n855 VSS.n854 70.0005
R483 VSS.n859 VSS.n858 70.0005
R484 VSS.n863 VSS.n862 70.0005
R485 VSS.n867 VSS.n833 70.0005
R486 VSS.n870 VSS.n823 70.0005
R487 VSS.n1240 VSS.n87 59.5005
R488 VSS.n1302 VSS.n136 59.5005
R489 VSS.n657 VSS.n541 59.5005
R490 VSS.n600 VSS.n418 59.5005
R491 VSS.n266 VSS.n88 59.5005
R492 VSS.n1338 VSS.n137 59.5005
R493 VSS.n914 VSS.n542 59.5005
R494 VSS.n985 VSS.n419 59.5005
R495 VSS.n1392 VSS.n89 59.5005
R496 VSS.n1368 VSS.n138 59.5005
R497 VSS.n938 VSS.n512 59.5005
R498 VSS.n1014 VSS.n421 59.5005
R499 VSS.n1415 VSS.n80 59.5005
R500 VSS.n1370 VSS.n130 59.5005
R501 VSS.n934 VSS.n503 59.5005
R502 VSS.n1016 VSS.n412 59.5005
R503 VSS.n190 VSS.n136 52.5005
R504 VSS.n190 VSS.n126 52.5005
R505 VSS.n1308 VSS.n126 52.5005
R506 VSS.n1308 VSS.n115 52.5005
R507 VSS.n235 VSS.n115 52.5005
R508 VSS.n235 VSS.n100 52.5005
R509 VSS.n1246 VSS.n100 52.5005
R510 VSS.n1246 VSS.n87 52.5005
R511 VSS.n1222 VSS.n70 52.5005
R512 VSS.n1228 VSS.n1227 52.5005
R513 VSS.n1232 VSS.n1231 52.5005
R514 VSS.n1238 VSS.n1237 52.5005
R515 VSS.n186 VSS.n134 52.5005
R516 VSS.n186 VSS.n124 52.5005
R517 VSS.n195 VSS.n124 52.5005
R518 VSS.n195 VSS.n111 52.5005
R519 VSS.n232 VSS.n111 52.5005
R520 VSS.n232 VSS.n98 52.5005
R521 VSS.n294 VSS.n98 52.5005
R522 VSS.n294 VSS.n86 52.5005
R523 VSS.n1290 VSS.n202 52.5005
R524 VSS.n1293 VSS.n1292 52.5005
R525 VSS.n1299 VSS.n199 52.5005
R526 VSS.n1302 VSS.n1301 52.5005
R527 VSS.n472 VSS.n418 52.5005
R528 VSS.n472 VSS.n405 52.5005
R529 VSS.n486 VSS.n405 52.5005
R530 VSS.n904 VSS.n486 52.5005
R531 VSS.n904 VSS.n498 52.5005
R532 VSS.n908 VSS.n498 52.5005
R533 VSS.n908 VSS.n510 52.5005
R534 VSS.n541 VSS.n510 52.5005
R535 VSS.n674 VSS.n524 52.5005
R536 VSS.n671 VSS.n670 52.5005
R537 VSS.n667 VSS.n666 52.5005
R538 VSS.n661 VSS.n660 52.5005
R539 VSS.n468 VSS.n416 52.5005
R540 VSS.n468 VSS.n403 52.5005
R541 VSS.n483 VSS.n403 52.5005
R542 VSS.n686 VSS.n483 52.5005
R543 VSS.n686 VSS.n495 52.5005
R544 VSS.n571 VSS.n495 52.5005
R545 VSS.n571 VSS.n508 52.5005
R546 VSS.n540 VSS.n508 52.5005
R547 VSS.n588 VSS.n578 52.5005
R548 VSS.n591 VSS.n590 52.5005
R549 VSS.n597 VSS.n575 52.5005
R550 VSS.n600 VSS.n599 52.5005
R551 VSS.n1342 VSS.n137 52.5005
R552 VSS.n1342 VSS.n127 52.5005
R553 VSS.n1310 VSS.n127 52.5005
R554 VSS.n1310 VSS.n116 52.5005
R555 VSS.n1252 VSS.n116 52.5005
R556 VSS.n1252 VSS.n101 52.5005
R557 VSS.n1248 VSS.n101 52.5005
R558 VSS.n1248 VSS.n88 52.5005
R559 VSS.n284 VSS.n72 52.5005
R560 VSS.n280 VSS.n279 52.5005
R561 VSS.n276 VSS.n275 52.5005
R562 VSS.n270 VSS.n269 52.5005
R563 VSS.n1344 VSS.n133 52.5005
R564 VSS.n1344 VSS.n123 52.5005
R565 VSS.n194 VSS.n123 52.5005
R566 VSS.n194 VSS.n110 52.5005
R567 VSS.n231 VSS.n110 52.5005
R568 VSS.n231 VSS.n97 52.5005
R569 VSS.n293 VSS.n97 52.5005
R570 VSS.n293 VSS.n85 52.5005
R571 VSS.n1326 VSS.n1319 52.5005
R572 VSS.n1329 VSS.n1328 52.5005
R573 VSS.n1335 VSS.n1314 52.5005
R574 VSS.n1338 VSS.n1337 52.5005
R575 VSS.n989 VSS.n419 52.5005
R576 VSS.n989 VSS.n406 52.5005
R577 VSS.n487 VSS.n406 52.5005
R578 VSS.n902 VSS.n487 52.5005
R579 VSS.n902 VSS.n499 52.5005
R580 VSS.n910 VSS.n499 52.5005
R581 VSS.n910 VSS.n511 52.5005
R582 VSS.n914 VSS.n511 52.5005
R583 VSS.n563 VSS.n526 52.5005
R584 VSS.n560 VSS.n559 52.5005
R585 VSS.n556 VSS.n555 52.5005
R586 VSS.n550 VSS.n549 52.5005
R587 VSS.n467 VSS.n415 52.5005
R588 VSS.n467 VSS.n402 52.5005
R589 VSS.n958 VSS.n402 52.5005
R590 VSS.n958 VSS.n480 52.5005
R591 VSS.n494 VSS.n480 52.5005
R592 VSS.n570 VSS.n494 52.5005
R593 VSS.n570 VSS.n507 52.5005
R594 VSS.n539 VSS.n507 52.5005
R595 VSS.n973 VSS.n478 52.5005
R596 VSS.n976 VSS.n975 52.5005
R597 VSS.n982 VSS.n475 52.5005
R598 VSS.n985 VSS.n984 52.5005
R599 VSS.n1368 VSS.n119 52.5005
R600 VSS.n1376 VSS.n119 52.5005
R601 VSS.n1376 VSS.n117 52.5005
R602 VSS.n1380 VSS.n117 52.5005
R603 VSS.n1380 VSS.n93 52.5005
R604 VSS.n1388 VSS.n93 52.5005
R605 VSS.n1388 VSS.n90 52.5005
R606 VSS.n1392 VSS.n90 52.5005
R607 VSS.n254 VSS.n65 52.5005
R608 VSS.n250 VSS.n249 52.5005
R609 VSS.n246 VSS.n245 52.5005
R610 VSS.n240 VSS.n239 52.5005
R611 VSS.n185 VSS.n132 52.5005
R612 VSS.n185 VSS.n122 52.5005
R613 VSS.n193 VSS.n122 52.5005
R614 VSS.n193 VSS.n109 52.5005
R615 VSS.n230 VSS.n109 52.5005
R616 VSS.n230 VSS.n96 52.5005
R617 VSS.n265 VSS.n96 52.5005
R618 VSS.n265 VSS.n84 52.5005
R619 VSS.n1355 VSS.n1354 52.5005
R620 VSS.n1359 VSS.n144 52.5005
R621 VSS.n1362 VSS.n1361 52.5005
R622 VSS.n1364 VSS.n138 52.5005
R623 VSS.n1014 VSS.n420 52.5005
R624 VSS.n420 VSS.n407 52.5005
R625 VSS.n956 VSS.n407 52.5005
R626 VSS.n956 VSS.n488 52.5005
R627 VSS.n951 VSS.n488 52.5005
R628 VSS.n951 VSS.n490 52.5005
R629 VSS.n942 VSS.n490 52.5005
R630 VSS.n942 VSS.n512 52.5005
R631 VSS.n644 VSS.n519 52.5005
R632 VSS.n641 VSS.n640 52.5005
R633 VSS.n637 VSS.n636 52.5005
R634 VSS.n631 VSS.n514 52.5005
R635 VSS.n466 VSS.n414 52.5005
R636 VSS.n466 VSS.n401 52.5005
R637 VSS.n482 VSS.n401 52.5005
R638 VSS.n655 VSS.n482 52.5005
R639 VSS.n655 VSS.n493 52.5005
R640 VSS.n547 VSS.n493 52.5005
R641 VSS.n547 VSS.n506 52.5005
R642 VSS.n538 VSS.n506 52.5005
R643 VSS.n1001 VSS.n1000 52.5005
R644 VSS.n1005 VSS.n428 52.5005
R645 VSS.n1008 VSS.n1007 52.5005
R646 VSS.n1010 VSS.n421 52.5005
R647 VSS.n1370 VSS.n128 52.5005
R648 VSS.n1374 VSS.n128 52.5005
R649 VSS.n1374 VSS.n106 52.5005
R650 VSS.n1382 VSS.n106 52.5005
R651 VSS.n1382 VSS.n103 52.5005
R652 VSS.n1386 VSS.n103 52.5005
R653 VSS.n1386 VSS.n102 52.5005
R654 VSS.n102 VSS.n80 52.5005
R655 VSS.n1397 VSS.n77 52.5005
R656 VSS.n1403 VSS.n1402 52.5005
R657 VSS.n1407 VSS.n1406 52.5005
R658 VSS.n1411 VSS.n79 52.5005
R659 VSS.n184 VSS.n131 52.5005
R660 VSS.n184 VSS.n121 52.5005
R661 VSS.n192 VSS.n121 52.5005
R662 VSS.n192 VSS.n108 52.5005
R663 VSS.n229 VSS.n108 52.5005
R664 VSS.n229 VSS.n95 52.5005
R665 VSS.n95 VSS.n83 52.5005
R666 VSS.n1394 VSS.n83 52.5005
R667 VSS.n174 VSS.n156 52.5005
R668 VSS.n170 VSS.n168 52.5005
R669 VSS.n166 VSS.n158 52.5005
R670 VSS.n160 VSS.n130 52.5005
R671 VSS.n1016 VSS.n409 52.5005
R672 VSS.n1020 VSS.n409 52.5005
R673 VSS.n1020 VSS.n408 52.5005
R674 VSS.n501 VSS.n408 52.5005
R675 VSS.n949 VSS.n501 52.5005
R676 VSS.n949 VSS.n500 52.5005
R677 VSS.n944 VSS.n500 52.5005
R678 VSS.n944 VSS.n503 52.5005
R679 VSS.n921 VSS.n920 52.5005
R680 VSS.n925 VSS.n924 52.5005
R681 VSS.n927 VSS.n534 52.5005
R682 VSS.n535 VSS.n534 52.5005
R683 VSS.n991 VSS.n413 52.5005
R684 VSS.n991 VSS.n400 52.5005
R685 VSS.n481 VSS.n400 52.5005
R686 VSS.n630 VSS.n481 52.5005
R687 VSS.n630 VSS.n492 52.5005
R688 VSS.n546 VSS.n492 52.5005
R689 VSS.n546 VSS.n505 52.5005
R690 VSS.n916 VSS.n505 52.5005
R691 VSS.n458 VSS.n440 52.5005
R692 VSS.n454 VSS.n452 52.5005
R693 VSS.n450 VSS.n442 52.5005
R694 VSS.n444 VSS.n412 52.5005
R695 VSS.n1105 VSS.n351 52.5005
R696 VSS.n1112 VSS.n351 52.5005
R697 VSS.n1116 VSS.n1115 52.5005
R698 VSS.n1118 VSS.n352 52.5005
R699 VSS.n1057 VSS.n374 52.5005
R700 VSS.n374 VSS.n373 52.5005
R701 VSS.n373 VSS.n372 52.5005
R702 VSS.n1051 VSS.n372 52.5005
R703 VSS.n1051 VSS.n368 52.5005
R704 VSS.n368 VSS.n367 52.5005
R705 VSS.n367 VSS.n366 52.5005
R706 VSS.n366 VSS.n356 52.5005
R707 VSS.n1101 VSS.n356 52.5005
R708 VSS.n1102 VSS.n1101 52.5005
R709 VSS.n1066 VSS.n1065 52.5005
R710 VSS.n1070 VSS.n1069 52.5005
R711 VSS.n1074 VSS.n383 52.5005
R712 VSS.n1077 VSS.n377 52.5005
R713 VSS.n1081 VSS.n375 52.5005
R714 VSS.n1081 VSS.n371 52.5005
R715 VSS.n1087 VSS.n371 52.5005
R716 VSS.n1087 VSS.n369 52.5005
R717 VSS.n1091 VSS.n369 52.5005
R718 VSS.n1091 VSS.n361 52.5005
R719 VSS.n1095 VSS.n361 52.5005
R720 VSS.n1095 VSS.n359 52.5005
R721 VSS.n1099 VSS.n359 52.5005
R722 VSS.n1099 VSS.n353 52.5005
R723 VSS.n1434 VSS.n8 50.7505
R724 VSS.n1436 VSS.n4 50.7505
R725 VSS.n1143 VSS.n346 50.7505
R726 VSS.n1175 VSS.n343 50.7505
R727 VSS.n758 VSS.n717 50.7505
R728 VSS.n730 VSS.n710 50.7505
R729 VSS.n839 VSS.n838 50.7505
R730 VSS.n870 VSS.n821 50.7505
R731 VSS.n1058 VSS.n1057 50.7505
R732 VSS.n1077 VSS.n375 50.7505
R733 VSS.n214 VSS.n210 42.0005
R734 VSS.n1256 VSS.n211 42.0005
R735 VSS.n1264 VSS.n206 42.0005
R736 VSS.n1269 VSS.n208 42.0005
R737 VSS.n619 VSS.n607 42.0005
R738 VSS.n614 VSS.n611 42.0005
R739 VSS.n1025 VSS.n393 42.0005
R740 VSS.n1030 VSS.n396 42.0005
R741 VSS.n86 VSS.n70 42.0005
R742 VSS.n1282 VSS.n134 42.0005
R743 VSS.n540 VSS.n524 42.0005
R744 VSS.n580 VSS.n416 42.0005
R745 VSS.n85 VSS.n72 42.0005
R746 VSS.n1317 VSS.n133 42.0005
R747 VSS.n539 VSS.n526 42.0005
R748 VSS.n965 VSS.n415 42.0005
R749 VSS.n84 VSS.n65 42.0005
R750 VSS.n1352 VSS.n132 42.0005
R751 VSS.n538 VSS.n519 42.0005
R752 VSS.n998 VSS.n414 42.0005
R753 VSS.n1394 VSS.n77 42.0005
R754 VSS.n176 VSS.n131 42.0005
R755 VSS.n917 VSS.n916 42.0005
R756 VSS.n460 VSS.n413 42.0005
R757 VSS.n1103 VSS.n1102 42.0005
R758 VSS.n1122 VSS.n353 42.0005
R759 VSS.n1434 VSS.n9 35.0005
R760 VSS.n1436 VSS.n5 35.0005
R761 VSS.n762 VSS.n717 35.0005
R762 VSS.n764 VSS.n710 35.0005
R763 VSS.n1273 VSS.n208 35.0005
R764 VSS.n1273 VSS.n114 35.0005
R765 VSS.n1258 VSS.n114 35.0005
R766 VSS.n1258 VSS.n210 35.0005
R767 VSS.n1274 VSS.n206 35.0005
R768 VSS.n1274 VSS.n112 35.0005
R769 VSS.n1257 VSS.n112 35.0005
R770 VSS.n1257 VSS.n1256 35.0005
R771 VSS.n1034 VSS.n396 35.0005
R772 VSS.n1034 VSS.n395 35.0005
R773 VSS.n623 VSS.n395 35.0005
R774 VSS.n623 VSS.n607 35.0005
R775 VSS.n1035 VSS.n393 35.0005
R776 VSS.n1035 VSS.n391 35.0005
R777 VSS.n606 VSS.n391 35.0005
R778 VSS.n611 VSS.n606 35.0005
R779 VSS.n1043 VSS.n1042 31.8896
R780 VSS.t235 VSS.n1093 31.6032
R781 VSS.t147 VSS.n350 31.6032
R782 VSS.n1439 VSS.n1 29.5408
R783 VSS.n218 VSS.n216 26.2505
R784 VSS.n1267 VSS.n1266 26.2505
R785 VSS.n617 VSS.n616 26.2505
R786 VSS.n1028 VSS.n1027 26.2505
R787 VSS.n995 VSS.n994 25.5037
R788 VSS.n1349 VSS.n178 25.5037
R789 VSS.n825 VSS.n824 23.8154
R790 VSS.n1178 VSS.n1177 23.8154
R791 VSS.n876 VSS.n875 23.126
R792 VSS.n1180 VSS.n344 23.126
R793 VSS.n763 VSS.n711 22.5739
R794 VSS.n1435 VSS.n7 22.5739
R795 VSS.n772 VSS.n771 22.2353
R796 VSS.n774 VSS.n773 22.2353
R797 VSS.n776 VSS.n775 22.2353
R798 VSS.n778 VSS.n777 22.2353
R799 VSS.n713 VSS.n707 22.2353
R800 VSS.n715 VSS.n714 22.2353
R801 VSS.n1420 VSS.n1419 22.2353
R802 VSS.n1422 VSS.n1421 22.2353
R803 VSS.n1424 VSS.n1423 22.2353
R804 VSS.n1426 VSS.n1425 22.2353
R805 VSS.n1428 VSS.n1427 22.2353
R806 VSS.n53 VSS.n52 22.2353
R807 VSS.n990 VSS.n470 20.9937
R808 VSS.n943 VSS.n504 20.9937
R809 VSS.n1343 VSS.n188 20.9937
R810 VSS.n1247 VSS.n237 20.9937
R811 VSS.n663 VSS.t35 20.9343
R812 VSS.n594 VSS.t31 20.9343
R813 VSS.n633 VSS.t137 20.9343
R814 VSS.n426 VSS.t42 20.9343
R815 VSS.n930 VSS.t218 20.9343
R816 VSS.n448 VSS.t134 20.9343
R817 VSS.n552 VSS.t52 20.9343
R818 VSS.n979 VSS.t148 20.9343
R819 VSS.n253 VSS.n252 20.8087
R820 VSS.n1400 VSS.n1399 20.8087
R821 VSS.n283 VSS.n282 20.8087
R822 VSS.n1225 VSS.n1224 20.8087
R823 VSS.n242 VSS.t190 20.7305
R824 VSS.n142 VSS.t48 20.7305
R825 VSS.n1410 VSS.t12 20.7305
R826 VSS.n164 VSS.t50 20.7305
R827 VSS.n272 VSS.t130 20.7305
R828 VSS.n1332 VSS.t37 20.7305
R829 VSS.n1235 VSS.t128 20.7305
R830 VSS.n1296 VSS.t210 20.7305
R831 VSS.n675 VSS.n673 20.6665
R832 VSS.n645 VSS.n643 20.6665
R833 VSS.n919 VSS.n536 20.6665
R834 VSS.n564 VSS.n562 20.6665
R835 VSS.n664 VSS.t36 20.3983
R836 VSS.n595 VSS.t32 20.3983
R837 VSS.n634 VSS.t138 20.3983
R838 VSS.n425 VSS.t43 20.3983
R839 VSS.n929 VSS.t219 20.3983
R840 VSS.n447 VSS.t135 20.3983
R841 VSS.n553 VSS.t53 20.3983
R842 VSS.n980 VSS.t149 20.3983
R843 VSS.n378 VSS.t16 20.3165
R844 VSS.n1093 VSS.t217 20.3165
R845 VSS.n243 VSS.t191 20.2975
R846 VSS.n141 VSS.t49 20.2975
R847 VSS.n1409 VSS.t13 20.2975
R848 VSS.n163 VSS.t51 20.2975
R849 VSS.n273 VSS.t131 20.2975
R850 VSS.n1333 VSS.t38 20.2975
R851 VSS.n1234 VSS.t129 20.2975
R852 VSS.n1297 VSS.t211 20.2975
R853 VSS.n1439 VSS.n1438 18.5479
R854 VSS.n728 VSS.n0 18.5479
R855 VSS.n878 VSS.n877 18.1721
R856 VSS.n903 VSS.n624 18.1721
R857 VSS.n1138 VSS.n1137 18.1721
R858 VSS.n1381 VSS.n107 18.1721
R859 VSS.t15 VSS.t14 18.0592
R860 VSS.t133 VSS.t229 18.0592
R861 VSS.n996 VSS.n995 18.0147
R862 VSS.n1350 VSS.n1349 18.0147
R863 VSS.n963 VSS.n388 17.9697
R864 VSS.n1348 VSS.n1347 17.9697
R865 VSS.n1040 VSS.n389 17.9614
R866 VSS.n1280 VSS.n1279 17.9614
R867 VSS.n880 VSS.n816 17.4826
R868 VSS.n809 VSS.n808 17.4826
R869 VSS.n1187 VSS.n1186 17.4826
R870 VSS.n336 VSS.n335 17.4826
R871 VSS.n1042 VSS.n0 14.9016
R872 VSS.n806 VSS.n424 14.7861
R873 VSS.n936 VSS.n515 14.7861
R874 VSS.n333 VSS.n140 14.7861
R875 VSS.n1418 VSS.n1417 14.7861
R876 VSS.n869 VSS.n825 14.6732
R877 VSS.n711 VSS.n379 14.6732
R878 VSS.n1076 VSS.n378 14.6732
R879 VSS.n1177 VSS.n1176 14.6732
R880 VSS.n1435 VSS.n6 14.6732
R881 VSS.n1042 VSS.n1041 14.6397
R882 VSS.n1038 VSS.t179 14.3735
R883 VSS.n1277 VSS.t7 14.3735
R884 VSS.n1039 VSS.t83 14.0135
R885 VSS.n1278 VSS.t237 14.0135
R886 VSS.n585 VSS.n584 13.0239
R887 VSS.n434 VSS.n433 13.0239
R888 VSS.n439 VSS.n438 13.0239
R889 VSS.n970 VSS.n969 13.0239
R890 VSS.n150 VSS.n149 13.0239
R891 VSS.n155 VSS.n154 13.0239
R892 VSS.n1323 VSS.n1322 13.0239
R893 VSS.n1287 VSS.n1286 13.0239
R894 VSS.n1063 VSS.n1062 13.022
R895 VSS.n387 VSS.n386 13.022
R896 VSS.n815 VSS.n814 12.5287
R897 VSS.n886 VSS.n810 12.5287
R898 VSS.n1189 VSS.n1188 12.5287
R899 VSS.n1191 VSS.n1190 12.5287
R900 VSS.t113 VSS.n572 12.4158
R901 VSS.t195 VSS.n99 12.4158
R902 VSS.n1110 VSS.n1109 12.392
R903 VSS.n816 VSS.n815 11.8393
R904 VSS.n886 VSS.n809 11.8393
R905 VSS.n1188 VSS.n1187 11.8393
R906 VSS.n1191 VSS.n336 11.8393
R907 VSS.n903 VSS.n899 11.2872
R908 VSS.n1381 VSS.n113 11.2872
R909 VSS.n470 VSS.t141 10.0456
R910 VSS.n773 VSS.t214 10.0456
R911 VSS.n776 VSS.t222 10.0456
R912 VSS.n713 VSS.t206 10.0456
R913 VSS.n188 VSS.t122 10.0456
R914 VSS.n1421 VSS.t41 10.0456
R915 VSS.n1424 VSS.t228 10.0456
R916 VSS.t180 VSS.n1428 10.0456
R917 VSS.n1038 VSS.n1037 9.66958
R918 VSS.n1277 VSS.n1276 9.66958
R919 VSS.n52 VSS.n51 9.0343
R920 VSS.n1427 VSS.n1426 9.0343
R921 VSS.n1423 VSS.n1422 9.0343
R922 VSS.n1419 VSS.n1418 9.0343
R923 VSS.n1212 VSS.n1211 9.0343
R924 VSS.n1254 VSS.n107 9.0343
R925 VSS.n207 VSS.n196 9.0343
R926 VSS.n183 VSS.n182 9.0343
R927 VSS.n334 VSS.n333 9.0343
R928 VSS.n1190 VSS.n1189 9.0343
R929 VSS.n1137 VSS.n340 9.0343
R930 VSS.n1179 VSS.n1178 9.0343
R931 VSS.n716 VSS.n715 9.0343
R932 VSS.n778 VSS.n707 9.0343
R933 VSS.n775 VSS.n774 9.0343
R934 VSS.n771 VSS.n515 9.0343
R935 VSS.n696 VSS.n509 9.0343
R936 VSS.n624 VSS.n491 9.0343
R937 VSS.n485 VSS.n394 9.0343
R938 VSS.n465 VSS.n464 9.0343
R939 VSS.n807 VSS.n806 9.0343
R940 VSS.n814 VSS.n810 9.0343
R941 VSS.n879 VSS.n878 9.0343
R942 VSS.n824 VSS.n820 9.0343
R943 VSS.n1082 VSS.t17 9.02985
R944 VSS.t232 VSS.n1082 9.02985
R945 VSS.t46 VSS.t104 9.02985
R946 VSS.t104 VSS.t45 9.02985
R947 VSS.t205 VSS.t121 9.02985
R948 VSS.t9 VSS.t205 9.02985
R949 VSS.n1092 VSS.t10 9.02985
R950 VSS.t145 VSS.n1092 9.02985
R951 VSS.t239 VSS.t108 9.02985
R952 VSS.t233 VSS.t239 9.02985
R953 VSS.t18 VSS.t74 9.02985
R954 VSS.t74 VSS.t231 9.02985
R955 VSS.n1124 VSS.n350 9.02985
R956 VSS.n697 VSS.t209 8.46551
R957 VSS.t206 VSS.n712 8.46551
R958 VSS.n321 VSS.t120 8.46551
R959 VSS.n1429 VSS.t180 8.46551
R960 VSS VSS.n1439 8.27337
R961 VSS.n1022 VSS.n1021 7.90118
R962 VSS.n909 VSS.n572 7.90118
R963 VSS.n1375 VSS.n120 7.90118
R964 VSS.n1387 VSS.n99 7.90118
R965 VSS VSS.n0 7.82892
R966 VSS.n824 VSS.t142 7.78831
R967 VSS.t143 VSS.n820 7.78831
R968 VSS.n878 VSS.t64 7.78831
R969 VSS.n879 VSS.t65 7.78831
R970 VSS.n814 VSS.t124 7.78831
R971 VSS.t125 VSS.n810 7.78831
R972 VSS.n807 VSS.t62 7.78831
R973 VSS.n806 VSS.t63 7.78831
R974 VSS.n771 VSS.t29 7.78831
R975 VSS.n774 VSS.t75 7.78831
R976 VSS.n775 VSS.t76 7.78831
R977 VSS.t215 VSS.n778 7.78831
R978 VSS.n715 VSS.t106 7.78831
R979 VSS.n716 VSS.t107 7.78831
R980 VSS.n1178 VSS.t57 7.78831
R981 VSS.n1179 VSS.t58 7.78831
R982 VSS.n1137 VSS.t77 7.78831
R983 VSS.t78 VSS.n340 7.78831
R984 VSS.n1189 VSS.t152 7.78831
R985 VSS.n1190 VSS.t153 7.78831
R986 VSS.n334 VSS.t39 7.78831
R987 VSS.n333 VSS.t40 7.78831
R988 VSS.n1419 VSS.t155 7.78831
R989 VSS.n1422 VSS.t139 7.78831
R990 VSS.n1423 VSS.t140 7.78831
R991 VSS.n1426 VSS.t150 7.78831
R992 VSS.n52 VSS.t79 7.78831
R993 VSS.n51 VSS.t80 7.78831
R994 VSS.n995 VSS.n388 7.53445
R995 VSS.n1349 VSS.n1348 7.53445
R996 VSS.n1041 VSS.n1040 7.49527
R997 VSS.n1279 VSS.n1 7.49527
R998 VSS.n936 VSS.n525 7.44971
R999 VSS.n1417 VSS.n71 7.44971
R1000 VSS.n1040 VSS.n1039 7.43328
R1001 VSS.n1279 VSS.n1278 7.43328
R1002 VSS.n1015 VSS.n417 7.22398
R1003 VSS.n915 VSS.n525 7.22398
R1004 VSS.n772 VSS.n770 7.22398
R1005 VSS.n777 VSS.n769 7.22398
R1006 VSS.n1369 VSS.n135 7.22398
R1007 VSS.n1393 VSS.n71 7.22398
R1008 VSS.n1420 VSS.n57 7.22398
R1009 VSS.n1425 VSS.n56 7.22398
R1010 VSS.n880 VSS.n879 6.88538
R1011 VSS.n808 VSS.n807 6.88538
R1012 VSS.n1021 VSS.n404 6.88538
R1013 VSS.n899 VSS.n394 6.88538
R1014 VSS.n909 VSS.n545 6.88538
R1015 VSS.n1186 VSS.n340 6.88538
R1016 VSS.n335 VSS.n334 6.88538
R1017 VSS.n1375 VSS.n125 6.88538
R1018 VSS.n207 VSS.n113 6.88538
R1019 VSS.n1387 VSS.n94 6.88538
R1020 VSS.n1109 VSS.n1107 6.3881
R1021 VSS.n1109 VSS.n1108 6.38518
R1022 VSS.n877 VSS.n876 6.19593
R1023 VSS.n1138 VSS.n344 6.19593
R1024 VSS.n584 VSS.n583 5.83696
R1025 VSS.n433 VSS.n432 5.83696
R1026 VSS.n438 VSS.n437 5.83696
R1027 VSS.n969 VSS.n968 5.83696
R1028 VSS.n584 VSS.n582 5.83371
R1029 VSS.n433 VSS.n431 5.83371
R1030 VSS.n438 VSS.n436 5.83371
R1031 VSS.n969 VSS.n967 5.83371
R1032 VSS.n1062 VSS.n1061 5.73984
R1033 VSS.n386 VSS.n385 5.73984
R1034 VSS.n1062 VSS.n1060 5.73692
R1035 VSS.n386 VSS.n384 5.73692
R1036 VSS.n465 VSS.n463 5.64384
R1037 VSS.n464 VSS.n404 5.64384
R1038 VSS.n957 VSS.t27 5.64384
R1039 VSS.t178 VSS.t27 5.64384
R1040 VSS.t82 VSS.t81 5.64384
R1041 VSS.n950 VSS.t81 5.64384
R1042 VSS.n695 VSS.n509 5.64384
R1043 VSS.n183 VSS.n181 5.64384
R1044 VSS.n182 VSS.n125 5.64384
R1045 VSS.n1309 VSS.t2 5.64384
R1046 VSS.t6 VSS.t2 5.64384
R1047 VSS.t236 VSS.t21 5.64384
R1048 VSS.n1253 VSS.t21 5.64384
R1049 VSS.n1212 VSS.n295 5.64384
R1050 VSS.n149 VSS.n148 5.5383
R1051 VSS.n154 VSS.n153 5.5383
R1052 VSS.n1322 VSS.n1321 5.5383
R1053 VSS.n1286 VSS.n1285 5.5383
R1054 VSS.n149 VSS.n147 5.53505
R1055 VSS.n154 VSS.n152 5.53505
R1056 VSS.n1322 VSS.n1320 5.53505
R1057 VSS.n1286 VSS.n1284 5.53505
R1058 VSS.n1428 VSS.n53 5.41246
R1059 VSS.n1425 VSS.n1424 5.41246
R1060 VSS.n1421 VSS.n1420 5.41246
R1061 VSS.n237 VSS.n71 5.41246
R1062 VSS.n188 VSS.n135 5.41246
R1063 VSS.n714 VSS.n713 5.41246
R1064 VSS.n777 VSS.n776 5.41246
R1065 VSS.n773 VSS.n772 5.41246
R1066 VSS.n525 VSS.n504 5.41246
R1067 VSS.n470 VSS.n417 5.41246
R1068 VSS.n4 VSS.n2 5.2005
R1069 VSS.n21 VSS.n18 5.2005
R1070 VSS.n23 VSS.n22 5.2005
R1071 VSS.n24 VSS.n17 5.2005
R1072 VSS.n26 VSS.n25 5.2005
R1073 VSS.n28 VSS.n15 5.2005
R1074 VSS.n30 VSS.n29 5.2005
R1075 VSS.n31 VSS.n14 5.2005
R1076 VSS.n33 VSS.n32 5.2005
R1077 VSS.n35 VSS.n13 5.2005
R1078 VSS.n36 VSS.n12 5.2005
R1079 VSS.n39 VSS.n38 5.2005
R1080 VSS.n11 VSS.n6 5.2005
R1081 VSS.n40 VSS.n11 5.2005
R1082 VSS.n42 VSS.n41 5.2005
R1083 VSS.n44 VSS.n10 5.2005
R1084 VSS.n47 VSS.n46 5.2005
R1085 VSS.n48 VSS.n8 5.2005
R1086 VSS.n1436 VSS.n1435 5.2005
R1087 VSS.n1437 VSS.n1436 5.2005
R1088 VSS.n7 VSS.n5 5.2005
R1089 VSS.n5 VSS.n3 5.2005
R1090 VSS.n1429 VSS.n54 5.2005
R1091 VSS.n312 VSS.n54 5.2005
R1092 VSS.n314 VSS.n55 5.2005
R1093 VSS.n314 VSS.n313 5.2005
R1094 VSS.n315 VSS.n56 5.2005
R1095 VSS.n316 VSS.n315 5.2005
R1096 VSS.n311 VSS.t223 5.2005
R1097 VSS.n317 VSS.n311 5.2005
R1098 VSS.n319 VSS.n57 5.2005
R1099 VSS.n319 VSS.n318 5.2005
R1100 VSS.n320 VSS.n58 5.2005
R1101 VSS.n320 VSS.n302 5.2005
R1102 VSS.n322 VSS.n321 5.2005
R1103 VSS.n323 VSS.n322 5.2005
R1104 VSS.n1210 VSS.n296 5.2005
R1105 VSS.n324 VSS.n296 5.2005
R1106 VSS.n1253 VSS.n233 5.2005
R1107 VSS.n325 VSS.n233 5.2005
R1108 VSS.n301 VSS.n113 5.2005
R1109 VSS.n326 VSS.n301 5.2005
R1110 VSS.n1203 VSS.n1202 5.2005
R1111 VSS.n1202 VSS.n1201 5.2005
R1112 VSS.n1343 VSS.n187 5.2005
R1113 VSS.n1200 VSS.n187 5.2005
R1114 VSS.n1198 VSS.n1197 5.2005
R1115 VSS.n1199 VSS.n1198 5.2005
R1116 VSS.n335 VSS.n328 5.2005
R1117 VSS.n328 VSS.n327 5.2005
R1118 VSS.n1191 VSS.n337 5.2005
R1119 VSS.n1134 VSS.n337 5.2005
R1120 VSS.n1188 VSS.n338 5.2005
R1121 VSS.n1135 VSS.n338 5.2005
R1122 VSS.n1186 VSS.n339 5.2005
R1123 VSS.n1136 VSS.n339 5.2005
R1124 VSS.n1139 VSS.n1138 5.2005
R1125 VSS.n1140 VSS.n1139 5.2005
R1126 VSS.n1180 VSS.n345 5.2005
R1127 VSS.n1141 VSS.n345 5.2005
R1128 VSS.n1177 VSS.n346 5.2005
R1129 VSS.n1142 VSS.n346 5.2005
R1130 VSS.n1176 VSS.n1175 5.2005
R1131 VSS.n1175 VSS.n1174 5.2005
R1132 VSS.n1173 VSS.n1133 5.2005
R1133 VSS.n1172 VSS.n1171 5.2005
R1134 VSS.n1170 VSS.n1169 5.2005
R1135 VSS.n1168 VSS.n1167 5.2005
R1136 VSS.n1166 VSS.n1165 5.2005
R1137 VSS.n1164 VSS.n1163 5.2005
R1138 VSS.n1162 VSS.n1161 5.2005
R1139 VSS.n1160 VSS.n1159 5.2005
R1140 VSS.n1158 VSS.n1157 5.2005
R1141 VSS.n1156 VSS.n1155 5.2005
R1142 VSS.n1154 VSS.n1153 5.2005
R1143 VSS.n1152 VSS.n1151 5.2005
R1144 VSS.n1150 VSS.n1149 5.2005
R1145 VSS.n1148 VSS.n1147 5.2005
R1146 VSS.n1146 VSS.n1145 5.2005
R1147 VSS.n1144 VSS.n1143 5.2005
R1148 VSS.n1435 VSS.n1434 5.2005
R1149 VSS.n1434 VSS.n1433 5.2005
R1150 VSS.n9 VSS.n7 5.2005
R1151 VSS.n1432 VSS.n9 5.2005
R1152 VSS.n1430 VSS.n1429 5.2005
R1153 VSS.n1431 VSS.n1430 5.2005
R1154 VSS.n55 VSS.n50 5.2005
R1155 VSS.n50 VSS.n49 5.2005
R1156 VSS.n303 VSS.n56 5.2005
R1157 VSS.n305 VSS.n303 5.2005
R1158 VSS.t223 VSS.n310 5.2005
R1159 VSS.n310 VSS.n309 5.2005
R1160 VSS.n304 VSS.n57 5.2005
R1161 VSS.n308 VSS.n304 5.2005
R1162 VSS.n306 VSS.n58 5.2005
R1163 VSS.n307 VSS.n306 5.2005
R1164 VSS.n321 VSS.n297 5.2005
R1165 VSS.n298 VSS.n297 5.2005
R1166 VSS.n1210 VSS.n1209 5.2005
R1167 VSS.n1209 VSS.n1208 5.2005
R1168 VSS.n1253 VSS.n234 5.2005
R1169 VSS.n1207 VSS.n234 5.2005
R1170 VSS.n1205 VSS.n113 5.2005
R1171 VSS.n1206 VSS.n1205 5.2005
R1172 VSS.n1204 VSS.n1203 5.2005
R1173 VSS.n1204 VSS.n299 5.2005
R1174 VSS.n1343 VSS.n189 5.2005
R1175 VSS.n330 VSS.n189 5.2005
R1176 VSS.n1197 VSS.n1196 5.2005
R1177 VSS.n1196 VSS.n1195 5.2005
R1178 VSS.n335 VSS.n329 5.2005
R1179 VSS.n1194 VSS.n329 5.2005
R1180 VSS.n1192 VSS.n1191 5.2005
R1181 VSS.n1193 VSS.n1192 5.2005
R1182 VSS.n1188 VSS.n332 5.2005
R1183 VSS.n332 VSS.n331 5.2005
R1184 VSS.n1186 VSS.n1185 5.2005
R1185 VSS.n1185 VSS.n1184 5.2005
R1186 VSS.n1138 VSS.n341 5.2005
R1187 VSS.n1183 VSS.n341 5.2005
R1188 VSS.n1181 VSS.n1180 5.2005
R1189 VSS.n1182 VSS.n1181 5.2005
R1190 VSS.n1177 VSS.n343 5.2005
R1191 VSS.n343 VSS.n342 5.2005
R1192 VSS.n378 VSS.n375 5.2005
R1193 VSS.n1079 VSS.n375 5.2005
R1194 VSS.n1082 VSS.n1081 5.2005
R1195 VSS.n1081 VSS.n1080 5.2005
R1196 VSS.n1085 VSS.n371 5.2005
R1197 VSS.n371 VSS.n370 5.2005
R1198 VSS.n1087 VSS.n1086 5.2005
R1199 VSS.n1088 VSS.n1087 5.2005
R1200 VSS.n1050 VSS.n369 5.2005
R1201 VSS.n1089 VSS.n369 5.2005
R1202 VSS.n1092 VSS.n1091 5.2005
R1203 VSS.n1091 VSS.n1090 5.2005
R1204 VSS.n1093 VSS.n361 5.2005
R1205 VSS.n361 VSS.n360 5.2005
R1206 VSS.n1095 VSS.n1094 5.2005
R1207 VSS.n1096 VSS.n1095 5.2005
R1208 VSS.n363 VSS.n359 5.2005
R1209 VSS.n1097 VSS.n359 5.2005
R1210 VSS.n1100 VSS.n1099 5.2005
R1211 VSS.n1099 VSS.n1098 5.2005
R1212 VSS.n353 VSS.n350 5.2005
R1213 VSS.n354 VSS.n353 5.2005
R1214 VSS.n1102 VSS.n350 5.2005
R1215 VSS.n1102 VSS.n355 5.2005
R1216 VSS.n1101 VSS.n1100 5.2005
R1217 VSS.n1101 VSS.n357 5.2005
R1218 VSS.n363 VSS.n356 5.2005
R1219 VSS.n1044 VSS.n356 5.2005
R1220 VSS.n1094 VSS.n366 5.2005
R1221 VSS.n1045 VSS.n366 5.2005
R1222 VSS.n1093 VSS.n367 5.2005
R1223 VSS.n1046 VSS.n367 5.2005
R1224 VSS.n1092 VSS.n368 5.2005
R1225 VSS.n1047 VSS.n368 5.2005
R1226 VSS.n1051 VSS.n1050 5.2005
R1227 VSS.n1052 VSS.n1051 5.2005
R1228 VSS.n1086 VSS.n372 5.2005
R1229 VSS.n1053 VSS.n372 5.2005
R1230 VSS.n1085 VSS.n373 5.2005
R1231 VSS.n1054 VSS.n373 5.2005
R1232 VSS.n1082 VSS.n374 5.2005
R1233 VSS.n1055 VSS.n374 5.2005
R1234 VSS.n1057 VSS.n378 5.2005
R1235 VSS.n1057 VSS.n1056 5.2005
R1236 VSS.n1077 VSS.n1076 5.2005
R1237 VSS.n1078 VSS.n1077 5.2005
R1238 VSS.n377 VSS.n376 5.2005
R1239 VSS.n1074 VSS.n1073 5.2005
R1240 VSS.n1072 VSS.n383 5.2005
R1241 VSS.n1071 VSS.n1070 5.2005
R1242 VSS.n1069 VSS.n1068 5.2005
R1243 VSS.n1067 VSS.n1066 5.2005
R1244 VSS.n1065 VSS.n1064 5.2005
R1245 VSS.n1059 VSS.n1058 5.2005
R1246 VSS.n1104 VSS.n1103 5.2005
R1247 VSS.n1106 VSS.n1105 5.2005
R1248 VSS.n1124 VSS.n351 5.2005
R1249 VSS.n1111 VSS.n351 5.2005
R1250 VSS.n1113 VSS.n1112 5.2005
R1251 VSS.n1115 VSS.n1114 5.2005
R1252 VSS.n1117 VSS.n1116 5.2005
R1253 VSS.n1119 VSS.n1118 5.2005
R1254 VSS.n1120 VSS.n352 5.2005
R1255 VSS.n1122 VSS.n1121 5.2005
R1256 VSS.n916 VSS.n915 5.2005
R1257 VSS.n916 VSS.n537 5.2005
R1258 VSS.n943 VSS.n505 5.2005
R1259 VSS.n625 VSS.n505 5.2005
R1260 VSS.n909 VSS.n546 5.2005
R1261 VSS.n626 VSS.n546 5.2005
R1262 VSS.n950 VSS.n492 5.2005
R1263 VSS.n627 VSS.n492 5.2005
R1264 VSS.n903 VSS.n630 5.2005
R1265 VSS.n630 VSS.n629 5.2005
R1266 VSS.n957 VSS.n481 5.2005
R1267 VSS.n628 VSS.n481 5.2005
R1268 VSS.n1021 VSS.n400 5.2005
R1269 VSS.n462 VSS.n400 5.2005
R1270 VSS.n991 VSS.n990 5.2005
R1271 VSS.n992 VSS.n991 5.2005
R1272 VSS.n1015 VSS.n413 5.2005
R1273 VSS.n993 VSS.n413 5.2005
R1274 VSS.n424 VSS.n412 5.2005
R1275 VSS.n412 VSS.n411 5.2005
R1276 VSS.n445 VSS.n444 5.2005
R1277 VSS.n446 VSS.n442 5.2005
R1278 VSS.n450 VSS.n449 5.2005
R1279 VSS.n452 VSS.n441 5.2005
R1280 VSS.n455 VSS.n454 5.2005
R1281 VSS.n456 VSS.n440 5.2005
R1282 VSS.n458 VSS.n457 5.2005
R1283 VSS.n461 VSS.n460 5.2005
R1284 VSS.n918 VSS.n917 5.2005
R1285 VSS.n920 VSS.n919 5.2005
R1286 VSS.n922 VSS.n921 5.2005
R1287 VSS.n924 VSS.n923 5.2005
R1288 VSS.n926 VSS.n925 5.2005
R1289 VSS.n928 VSS.n927 5.2005
R1290 VSS.n936 VSS.n534 5.2005
R1291 VSS.n931 VSS.n534 5.2005
R1292 VSS.n932 VSS.n535 5.2005
R1293 VSS.n934 VSS.n933 5.2005
R1294 VSS.n915 VSS.n503 5.2005
R1295 VSS.n503 VSS.n502 5.2005
R1296 VSS.n944 VSS.n943 5.2005
R1297 VSS.n945 VSS.n944 5.2005
R1298 VSS.n909 VSS.n500 5.2005
R1299 VSS.n946 VSS.n500 5.2005
R1300 VSS.n950 VSS.n949 5.2005
R1301 VSS.n949 VSS.n948 5.2005
R1302 VSS.n903 VSS.n501 5.2005
R1303 VSS.n947 VSS.n501 5.2005
R1304 VSS.n957 VSS.n408 5.2005
R1305 VSS.n410 VSS.n408 5.2005
R1306 VSS.n1021 VSS.n1020 5.2005
R1307 VSS.n1020 VSS.n1019 5.2005
R1308 VSS.n990 VSS.n409 5.2005
R1309 VSS.n1018 VSS.n409 5.2005
R1310 VSS.n1016 VSS.n1015 5.2005
R1311 VSS.n1017 VSS.n1016 5.2005
R1312 VSS.n1394 VSS.n1393 5.2005
R1313 VSS.n1395 VSS.n1394 5.2005
R1314 VSS.n1247 VSS.n83 5.2005
R1315 VSS.n83 VSS.n82 5.2005
R1316 VSS.n1387 VSS.n95 5.2005
R1317 VSS.n222 VSS.n95 5.2005
R1318 VSS.n1253 VSS.n229 5.2005
R1319 VSS.n229 VSS.n228 5.2005
R1320 VSS.n1381 VSS.n108 5.2005
R1321 VSS.n227 VSS.n108 5.2005
R1322 VSS.n1309 VSS.n192 5.2005
R1323 VSS.n226 VSS.n192 5.2005
R1324 VSS.n1375 VSS.n121 5.2005
R1325 VSS.n225 VSS.n121 5.2005
R1326 VSS.n1343 VSS.n184 5.2005
R1327 VSS.n224 VSS.n184 5.2005
R1328 VSS.n1369 VSS.n131 5.2005
R1329 VSS.n223 VSS.n131 5.2005
R1330 VSS.n140 VSS.n130 5.2005
R1331 VSS.n130 VSS.n129 5.2005
R1332 VSS.n161 VSS.n160 5.2005
R1333 VSS.n162 VSS.n158 5.2005
R1334 VSS.n166 VSS.n165 5.2005
R1335 VSS.n168 VSS.n157 5.2005
R1336 VSS.n171 VSS.n170 5.2005
R1337 VSS.n172 VSS.n156 5.2005
R1338 VSS.n174 VSS.n173 5.2005
R1339 VSS.n177 VSS.n176 5.2005
R1340 VSS.n1417 VSS.n77 5.2005
R1341 VSS.n1396 VSS.n77 5.2005
R1342 VSS.n1398 VSS.n1397 5.2005
R1343 VSS.n1402 VSS.n1401 5.2005
R1344 VSS.n1404 VSS.n1403 5.2005
R1345 VSS.n1406 VSS.n1405 5.2005
R1346 VSS.n1408 VSS.n1407 5.2005
R1347 VSS.n1412 VSS.n1411 5.2005
R1348 VSS.n1413 VSS.n79 5.2005
R1349 VSS.n1415 VSS.n1414 5.2005
R1350 VSS.n1393 VSS.n80 5.2005
R1351 VSS.n81 VSS.n80 5.2005
R1352 VSS.n1247 VSS.n102 5.2005
R1353 VSS.n104 VSS.n102 5.2005
R1354 VSS.n1387 VSS.n1386 5.2005
R1355 VSS.n1386 VSS.n1385 5.2005
R1356 VSS.n1253 VSS.n103 5.2005
R1357 VSS.n1384 VSS.n103 5.2005
R1358 VSS.n1382 VSS.n1381 5.2005
R1359 VSS.n1383 VSS.n1382 5.2005
R1360 VSS.n1309 VSS.n106 5.2005
R1361 VSS.n106 VSS.n105 5.2005
R1362 VSS.n1375 VSS.n1374 5.2005
R1363 VSS.n1374 VSS.n1373 5.2005
R1364 VSS.n1343 VSS.n128 5.2005
R1365 VSS.n1372 VSS.n128 5.2005
R1366 VSS.n1370 VSS.n1369 5.2005
R1367 VSS.n1371 VSS.n1370 5.2005
R1368 VSS.n915 VSS.n538 5.2005
R1369 VSS.n647 VSS.n538 5.2005
R1370 VSS.n943 VSS.n506 5.2005
R1371 VSS.n648 VSS.n506 5.2005
R1372 VSS.n909 VSS.n547 5.2005
R1373 VSS.n649 VSS.n547 5.2005
R1374 VSS.n950 VSS.n493 5.2005
R1375 VSS.n650 VSS.n493 5.2005
R1376 VSS.n903 VSS.n655 5.2005
R1377 VSS.n655 VSS.n654 5.2005
R1378 VSS.n957 VSS.n482 5.2005
R1379 VSS.n653 VSS.n482 5.2005
R1380 VSS.n1021 VSS.n401 5.2005
R1381 VSS.n652 VSS.n401 5.2005
R1382 VSS.n990 VSS.n466 5.2005
R1383 VSS.n651 VSS.n466 5.2005
R1384 VSS.n1015 VSS.n414 5.2005
R1385 VSS.n435 VSS.n414 5.2005
R1386 VSS.n424 VSS.n421 5.2005
R1387 VSS.n1012 VSS.n421 5.2005
R1388 VSS.n1011 VSS.n1010 5.2005
R1389 VSS.n1008 VSS.n423 5.2005
R1390 VSS.n1007 VSS.n427 5.2005
R1391 VSS.n1005 VSS.n1004 5.2005
R1392 VSS.n1003 VSS.n428 5.2005
R1393 VSS.n1002 VSS.n1001 5.2005
R1394 VSS.n1000 VSS.n429 5.2005
R1395 VSS.n998 VSS.n997 5.2005
R1396 VSS.n936 VSS.n519 5.2005
R1397 VSS.n646 VSS.n519 5.2005
R1398 VSS.n645 VSS.n644 5.2005
R1399 VSS.n642 VSS.n641 5.2005
R1400 VSS.n640 VSS.n639 5.2005
R1401 VSS.n638 VSS.n637 5.2005
R1402 VSS.n636 VSS.n635 5.2005
R1403 VSS.n632 VSS.n631 5.2005
R1404 VSS.n514 VSS.n513 5.2005
R1405 VSS.n939 VSS.n938 5.2005
R1406 VSS.n915 VSS.n512 5.2005
R1407 VSS.n940 VSS.n512 5.2005
R1408 VSS.n943 VSS.n942 5.2005
R1409 VSS.n942 VSS.n941 5.2005
R1410 VSS.n909 VSS.n490 5.2005
R1411 VSS.n490 VSS.n489 5.2005
R1412 VSS.n951 VSS.n950 5.2005
R1413 VSS.n952 VSS.n951 5.2005
R1414 VSS.n903 VSS.n488 5.2005
R1415 VSS.n953 VSS.n488 5.2005
R1416 VSS.n957 VSS.n956 5.2005
R1417 VSS.n956 VSS.n955 5.2005
R1418 VSS.n1021 VSS.n407 5.2005
R1419 VSS.n954 VSS.n407 5.2005
R1420 VSS.n990 VSS.n420 5.2005
R1421 VSS.n422 VSS.n420 5.2005
R1422 VSS.n1015 VSS.n1014 5.2005
R1423 VSS.n1014 VSS.n1013 5.2005
R1424 VSS.n1393 VSS.n84 5.2005
R1425 VSS.n257 VSS.n84 5.2005
R1426 VSS.n1247 VSS.n265 5.2005
R1427 VSS.n265 VSS.n264 5.2005
R1428 VSS.n1387 VSS.n96 5.2005
R1429 VSS.n263 VSS.n96 5.2005
R1430 VSS.n1253 VSS.n230 5.2005
R1431 VSS.n262 VSS.n230 5.2005
R1432 VSS.n1381 VSS.n109 5.2005
R1433 VSS.n261 VSS.n109 5.2005
R1434 VSS.n1309 VSS.n193 5.2005
R1435 VSS.n260 VSS.n193 5.2005
R1436 VSS.n1375 VSS.n122 5.2005
R1437 VSS.n259 VSS.n122 5.2005
R1438 VSS.n1343 VSS.n185 5.2005
R1439 VSS.n258 VSS.n185 5.2005
R1440 VSS.n1369 VSS.n132 5.2005
R1441 VSS.n151 VSS.n132 5.2005
R1442 VSS.n140 VSS.n138 5.2005
R1443 VSS.n1366 VSS.n138 5.2005
R1444 VSS.n1365 VSS.n1364 5.2005
R1445 VSS.n1362 VSS.n139 5.2005
R1446 VSS.n1361 VSS.n143 5.2005
R1447 VSS.n1359 VSS.n1358 5.2005
R1448 VSS.n1357 VSS.n144 5.2005
R1449 VSS.n1356 VSS.n1355 5.2005
R1450 VSS.n1354 VSS.n145 5.2005
R1451 VSS.n1352 VSS.n1351 5.2005
R1452 VSS.n1417 VSS.n65 5.2005
R1453 VSS.n256 VSS.n65 5.2005
R1454 VSS.n255 VSS.n254 5.2005
R1455 VSS.n251 VSS.n250 5.2005
R1456 VSS.n249 VSS.n248 5.2005
R1457 VSS.n247 VSS.n246 5.2005
R1458 VSS.n245 VSS.n244 5.2005
R1459 VSS.n241 VSS.n240 5.2005
R1460 VSS.n239 VSS.n238 5.2005
R1461 VSS.n91 VSS.n89 5.2005
R1462 VSS.n1393 VSS.n1392 5.2005
R1463 VSS.n1392 VSS.n1391 5.2005
R1464 VSS.n1247 VSS.n90 5.2005
R1465 VSS.n1390 VSS.n90 5.2005
R1466 VSS.n1388 VSS.n1387 5.2005
R1467 VSS.n1389 VSS.n1388 5.2005
R1468 VSS.n1253 VSS.n93 5.2005
R1469 VSS.n93 VSS.n92 5.2005
R1470 VSS.n1381 VSS.n1380 5.2005
R1471 VSS.n1380 VSS.n1379 5.2005
R1472 VSS.n1309 VSS.n117 5.2005
R1473 VSS.n1378 VSS.n117 5.2005
R1474 VSS.n1376 VSS.n1375 5.2005
R1475 VSS.n1377 VSS.n1376 5.2005
R1476 VSS.n1343 VSS.n119 5.2005
R1477 VSS.n119 VSS.n118 5.2005
R1478 VSS.n1369 VSS.n1368 5.2005
R1479 VSS.n1368 VSS.n1367 5.2005
R1480 VSS.n915 VSS.n539 5.2005
R1481 VSS.n566 VSS.n539 5.2005
R1482 VSS.n943 VSS.n507 5.2005
R1483 VSS.n567 VSS.n507 5.2005
R1484 VSS.n909 VSS.n570 5.2005
R1485 VSS.n570 VSS.n569 5.2005
R1486 VSS.n950 VSS.n494 5.2005
R1487 VSS.n568 VSS.n494 5.2005
R1488 VSS.n903 VSS.n480 5.2005
R1489 VSS.n480 VSS.n479 5.2005
R1490 VSS.n958 VSS.n957 5.2005
R1491 VSS.n959 VSS.n958 5.2005
R1492 VSS.n1021 VSS.n402 5.2005
R1493 VSS.n960 VSS.n402 5.2005
R1494 VSS.n990 VSS.n467 5.2005
R1495 VSS.n961 VSS.n467 5.2005
R1496 VSS.n1015 VSS.n415 5.2005
R1497 VSS.n962 VSS.n415 5.2005
R1498 VSS.n985 VSS.n424 5.2005
R1499 VSS.n986 VSS.n985 5.2005
R1500 VSS.n984 VSS.n474 5.2005
R1501 VSS.n982 VSS.n981 5.2005
R1502 VSS.n978 VSS.n475 5.2005
R1503 VSS.n977 VSS.n976 5.2005
R1504 VSS.n975 VSS.n476 5.2005
R1505 VSS.n973 VSS.n972 5.2005
R1506 VSS.n971 VSS.n478 5.2005
R1507 VSS.n966 VSS.n965 5.2005
R1508 VSS.n936 VSS.n526 5.2005
R1509 VSS.n565 VSS.n526 5.2005
R1510 VSS.n564 VSS.n563 5.2005
R1511 VSS.n561 VSS.n560 5.2005
R1512 VSS.n559 VSS.n558 5.2005
R1513 VSS.n557 VSS.n556 5.2005
R1514 VSS.n555 VSS.n554 5.2005
R1515 VSS.n551 VSS.n550 5.2005
R1516 VSS.n549 VSS.n548 5.2005
R1517 VSS.n543 VSS.n542 5.2005
R1518 VSS.n915 VSS.n914 5.2005
R1519 VSS.n914 VSS.n913 5.2005
R1520 VSS.n943 VSS.n511 5.2005
R1521 VSS.n912 VSS.n511 5.2005
R1522 VSS.n910 VSS.n909 5.2005
R1523 VSS.n911 VSS.n910 5.2005
R1524 VSS.n950 VSS.n499 5.2005
R1525 VSS.n544 VSS.n499 5.2005
R1526 VSS.n903 VSS.n902 5.2005
R1527 VSS.n902 VSS.n901 5.2005
R1528 VSS.n957 VSS.n487 5.2005
R1529 VSS.n900 VSS.n487 5.2005
R1530 VSS.n1021 VSS.n406 5.2005
R1531 VSS.n473 VSS.n406 5.2005
R1532 VSS.n990 VSS.n989 5.2005
R1533 VSS.n989 VSS.n988 5.2005
R1534 VSS.n1015 VSS.n419 5.2005
R1535 VSS.n987 VSS.n419 5.2005
R1536 VSS.n1393 VSS.n85 5.2005
R1537 VSS.n287 VSS.n85 5.2005
R1538 VSS.n1247 VSS.n293 5.2005
R1539 VSS.n293 VSS.n292 5.2005
R1540 VSS.n1387 VSS.n97 5.2005
R1541 VSS.n291 VSS.n97 5.2005
R1542 VSS.n1253 VSS.n231 5.2005
R1543 VSS.n290 VSS.n231 5.2005
R1544 VSS.n1381 VSS.n110 5.2005
R1545 VSS.n289 VSS.n110 5.2005
R1546 VSS.n1309 VSS.n194 5.2005
R1547 VSS.n288 VSS.n194 5.2005
R1548 VSS.n1375 VSS.n123 5.2005
R1549 VSS.n180 VSS.n123 5.2005
R1550 VSS.n1344 VSS.n1343 5.2005
R1551 VSS.n1345 VSS.n1344 5.2005
R1552 VSS.n1369 VSS.n133 5.2005
R1553 VSS.n1346 VSS.n133 5.2005
R1554 VSS.n1338 VSS.n140 5.2005
R1555 VSS.n1339 VSS.n1338 5.2005
R1556 VSS.n1337 VSS.n1313 5.2005
R1557 VSS.n1335 VSS.n1334 5.2005
R1558 VSS.n1331 VSS.n1314 5.2005
R1559 VSS.n1330 VSS.n1329 5.2005
R1560 VSS.n1328 VSS.n1315 5.2005
R1561 VSS.n1326 VSS.n1325 5.2005
R1562 VSS.n1324 VSS.n1319 5.2005
R1563 VSS.n1317 VSS.n179 5.2005
R1564 VSS.n1417 VSS.n72 5.2005
R1565 VSS.n286 VSS.n72 5.2005
R1566 VSS.n285 VSS.n284 5.2005
R1567 VSS.n281 VSS.n280 5.2005
R1568 VSS.n279 VSS.n278 5.2005
R1569 VSS.n277 VSS.n276 5.2005
R1570 VSS.n275 VSS.n274 5.2005
R1571 VSS.n271 VSS.n270 5.2005
R1572 VSS.n269 VSS.n268 5.2005
R1573 VSS.n267 VSS.n266 5.2005
R1574 VSS.n1393 VSS.n88 5.2005
R1575 VSS.n236 VSS.n88 5.2005
R1576 VSS.n1248 VSS.n1247 5.2005
R1577 VSS.n1249 VSS.n1248 5.2005
R1578 VSS.n1387 VSS.n101 5.2005
R1579 VSS.n1250 VSS.n101 5.2005
R1580 VSS.n1253 VSS.n1252 5.2005
R1581 VSS.n1252 VSS.n1251 5.2005
R1582 VSS.n1381 VSS.n116 5.2005
R1583 VSS.n191 VSS.n116 5.2005
R1584 VSS.n1310 VSS.n1309 5.2005
R1585 VSS.n1311 VSS.n1310 5.2005
R1586 VSS.n1375 VSS.n127 5.2005
R1587 VSS.n1312 VSS.n127 5.2005
R1588 VSS.n1343 VSS.n1342 5.2005
R1589 VSS.n1342 VSS.n1341 5.2005
R1590 VSS.n1369 VSS.n137 5.2005
R1591 VSS.n1340 VSS.n137 5.2005
R1592 VSS.n915 VSS.n540 5.2005
R1593 VSS.n677 VSS.n540 5.2005
R1594 VSS.n943 VSS.n508 5.2005
R1595 VSS.n678 VSS.n508 5.2005
R1596 VSS.n909 VSS.n571 5.2005
R1597 VSS.n679 VSS.n571 5.2005
R1598 VSS.n950 VSS.n495 5.2005
R1599 VSS.n680 VSS.n495 5.2005
R1600 VSS.n903 VSS.n686 5.2005
R1601 VSS.n686 VSS.n685 5.2005
R1602 VSS.n957 VSS.n483 5.2005
R1603 VSS.n684 VSS.n483 5.2005
R1604 VSS.n1021 VSS.n403 5.2005
R1605 VSS.n683 VSS.n403 5.2005
R1606 VSS.n990 VSS.n468 5.2005
R1607 VSS.n682 VSS.n468 5.2005
R1608 VSS.n1015 VSS.n416 5.2005
R1609 VSS.n681 VSS.n416 5.2005
R1610 VSS.n600 VSS.n424 5.2005
R1611 VSS.n601 VSS.n600 5.2005
R1612 VSS.n599 VSS.n574 5.2005
R1613 VSS.n597 VSS.n596 5.2005
R1614 VSS.n593 VSS.n575 5.2005
R1615 VSS.n592 VSS.n591 5.2005
R1616 VSS.n590 VSS.n576 5.2005
R1617 VSS.n588 VSS.n587 5.2005
R1618 VSS.n586 VSS.n578 5.2005
R1619 VSS.n581 VSS.n580 5.2005
R1620 VSS.n936 VSS.n524 5.2005
R1621 VSS.n676 VSS.n524 5.2005
R1622 VSS.n675 VSS.n674 5.2005
R1623 VSS.n672 VSS.n671 5.2005
R1624 VSS.n670 VSS.n669 5.2005
R1625 VSS.n668 VSS.n667 5.2005
R1626 VSS.n666 VSS.n665 5.2005
R1627 VSS.n662 VSS.n661 5.2005
R1628 VSS.n660 VSS.n659 5.2005
R1629 VSS.n658 VSS.n657 5.2005
R1630 VSS.n915 VSS.n541 5.2005
R1631 VSS.n656 VSS.n541 5.2005
R1632 VSS.n943 VSS.n510 5.2005
R1633 VSS.n573 VSS.n510 5.2005
R1634 VSS.n909 VSS.n908 5.2005
R1635 VSS.n908 VSS.n907 5.2005
R1636 VSS.n950 VSS.n498 5.2005
R1637 VSS.n906 VSS.n498 5.2005
R1638 VSS.n904 VSS.n903 5.2005
R1639 VSS.n905 VSS.n904 5.2005
R1640 VSS.n957 VSS.n486 5.2005
R1641 VSS.n605 VSS.n486 5.2005
R1642 VSS.n1021 VSS.n405 5.2005
R1643 VSS.n604 VSS.n405 5.2005
R1644 VSS.n990 VSS.n472 5.2005
R1645 VSS.n603 VSS.n472 5.2005
R1646 VSS.n1015 VSS.n418 5.2005
R1647 VSS.n602 VSS.n418 5.2005
R1648 VSS.n1393 VSS.n86 5.2005
R1649 VSS.n1220 VSS.n86 5.2005
R1650 VSS.n1247 VSS.n294 5.2005
R1651 VSS.n1219 VSS.n294 5.2005
R1652 VSS.n1387 VSS.n98 5.2005
R1653 VSS.n1218 VSS.n98 5.2005
R1654 VSS.n1253 VSS.n232 5.2005
R1655 VSS.n1217 VSS.n232 5.2005
R1656 VSS.n1381 VSS.n111 5.2005
R1657 VSS.n1216 VSS.n111 5.2005
R1658 VSS.n1309 VSS.n195 5.2005
R1659 VSS.n1215 VSS.n195 5.2005
R1660 VSS.n1375 VSS.n124 5.2005
R1661 VSS.n1214 VSS.n124 5.2005
R1662 VSS.n1343 VSS.n186 5.2005
R1663 VSS.n1213 VSS.n186 5.2005
R1664 VSS.n1369 VSS.n134 5.2005
R1665 VSS.n203 VSS.n134 5.2005
R1666 VSS.n1302 VSS.n140 5.2005
R1667 VSS.n1303 VSS.n1302 5.2005
R1668 VSS.n1301 VSS.n198 5.2005
R1669 VSS.n1299 VSS.n1298 5.2005
R1670 VSS.n1295 VSS.n199 5.2005
R1671 VSS.n1294 VSS.n1293 5.2005
R1672 VSS.n1292 VSS.n200 5.2005
R1673 VSS.n1290 VSS.n1289 5.2005
R1674 VSS.n1288 VSS.n202 5.2005
R1675 VSS.n1283 VSS.n1282 5.2005
R1676 VSS.n1417 VSS.n70 5.2005
R1677 VSS.n1221 VSS.n70 5.2005
R1678 VSS.n1223 VSS.n1222 5.2005
R1679 VSS.n1227 VSS.n1226 5.2005
R1680 VSS.n1229 VSS.n1228 5.2005
R1681 VSS.n1231 VSS.n1230 5.2005
R1682 VSS.n1233 VSS.n1232 5.2005
R1683 VSS.n1237 VSS.n1236 5.2005
R1684 VSS.n1239 VSS.n1238 5.2005
R1685 VSS.n1241 VSS.n1240 5.2005
R1686 VSS.n1393 VSS.n87 5.2005
R1687 VSS.n1242 VSS.n87 5.2005
R1688 VSS.n1247 VSS.n1246 5.2005
R1689 VSS.n1246 VSS.n1245 5.2005
R1690 VSS.n1387 VSS.n100 5.2005
R1691 VSS.n1244 VSS.n100 5.2005
R1692 VSS.n1253 VSS.n235 5.2005
R1693 VSS.n1243 VSS.n235 5.2005
R1694 VSS.n1381 VSS.n115 5.2005
R1695 VSS.n197 VSS.n115 5.2005
R1696 VSS.n1309 VSS.n1308 5.2005
R1697 VSS.n1308 VSS.n1307 5.2005
R1698 VSS.n1375 VSS.n126 5.2005
R1699 VSS.n1306 VSS.n126 5.2005
R1700 VSS.n1343 VSS.n190 5.2005
R1701 VSS.n1305 VSS.n190 5.2005
R1702 VSS.n1369 VSS.n136 5.2005
R1703 VSS.n1304 VSS.n136 5.2005
R1704 VSS.n611 VSS.n610 5.2005
R1705 VSS.n612 VSS.n611 5.2005
R1706 VSS.t82 VSS.n606 5.2005
R1707 VSS.n606 VSS.n390 5.2005
R1708 VSS.n903 VSS.n391 5.2005
R1709 VSS.n1037 VSS.n391 5.2005
R1710 VSS.n1035 VSS.t178 5.2005
R1711 VSS.n1036 VSS.n1035 5.2005
R1712 VSS.n484 VSS.n393 5.2005
R1713 VSS.n393 VSS.n392 5.2005
R1714 VSS.n1031 VSS.n1030 5.2005
R1715 VSS.n1028 VSS.n398 5.2005
R1716 VSS.n1027 VSS.n1023 5.2005
R1717 VSS.n1025 VSS.n1024 5.2005
R1718 VSS.n614 VSS.n613 5.2005
R1719 VSS.n616 VSS.n609 5.2005
R1720 VSS.n617 VSS.n608 5.2005
R1721 VSS.n620 VSS.n619 5.2005
R1722 VSS.n610 VSS.n607 5.2005
R1723 VSS.n621 VSS.n607 5.2005
R1724 VSS.t82 VSS.n623 5.2005
R1725 VSS.n623 VSS.n622 5.2005
R1726 VSS.n903 VSS.n395 5.2005
R1727 VSS.n397 VSS.n395 5.2005
R1728 VSS.t178 VSS.n1034 5.2005
R1729 VSS.n1034 VSS.n1033 5.2005
R1730 VSS.n484 VSS.n396 5.2005
R1731 VSS.n1032 VSS.n396 5.2005
R1732 VSS.n1256 VSS.n1255 5.2005
R1733 VSS.n1256 VSS.n221 5.2005
R1734 VSS.t236 VSS.n1257 5.2005
R1735 VSS.n1257 VSS.n204 5.2005
R1736 VSS.n1381 VSS.n112 5.2005
R1737 VSS.n1276 VSS.n112 5.2005
R1738 VSS.n1274 VSS.t6 5.2005
R1739 VSS.n1275 VSS.n1274 5.2005
R1740 VSS.n300 VSS.n206 5.2005
R1741 VSS.n206 VSS.n205 5.2005
R1742 VSS.n1270 VSS.n1269 5.2005
R1743 VSS.n1267 VSS.n1261 5.2005
R1744 VSS.n1266 VSS.n1262 5.2005
R1745 VSS.n1264 VSS.n1263 5.2005
R1746 VSS.n220 VSS.n211 5.2005
R1747 VSS.n219 VSS.n218 5.2005
R1748 VSS.n216 VSS.n212 5.2005
R1749 VSS.n214 VSS.n213 5.2005
R1750 VSS.n1255 VSS.n210 5.2005
R1751 VSS.n210 VSS.n209 5.2005
R1752 VSS.n1258 VSS.t236 5.2005
R1753 VSS.n1259 VSS.n1258 5.2005
R1754 VSS.n1381 VSS.n114 5.2005
R1755 VSS.n1260 VSS.n114 5.2005
R1756 VSS.t6 VSS.n1273 5.2005
R1757 VSS.n1273 VSS.n1272 5.2005
R1758 VSS.n300 VSS.n208 5.2005
R1759 VSS.n1271 VSS.n208 5.2005
R1760 VSS.n711 VSS.n710 5.2005
R1761 VSS.n710 VSS.n709 5.2005
R1762 VSS.n764 VSS.n763 5.2005
R1763 VSS.n765 VSS.n764 5.2005
R1764 VSS.n712 VSS.n708 5.2005
R1765 VSS.n766 VSS.n708 5.2005
R1766 VSS.n779 VSS.n768 5.2005
R1767 VSS.n768 VSS.n767 5.2005
R1768 VSS.n769 VSS.n703 5.2005
R1769 VSS.n703 VSS.n702 5.2005
R1770 VSS.n785 VSS.t230 5.2005
R1771 VSS.n786 VSS.n785 5.2005
R1772 VSS.n770 VSS.n701 5.2005
R1773 VSS.n787 VSS.n701 5.2005
R1774 VSS.n790 VSS.n789 5.2005
R1775 VSS.n789 VSS.n788 5.2005
R1776 VSS.n697 VSS.n694 5.2005
R1777 VSS.n694 VSS.n693 5.2005
R1778 VSS.n797 VSS.n796 5.2005
R1779 VSS.n798 VSS.n797 5.2005
R1780 VSS.n950 VSS.n496 5.2005
R1781 VSS.n799 VSS.n496 5.2005
R1782 VSS.n899 VSS.n687 5.2005
R1783 VSS.n800 VSS.n687 5.2005
R1784 VSS.n801 VSS.n399 5.2005
R1785 VSS.n802 VSS.n801 5.2005
R1786 VSS.n990 VSS.n469 5.2005
R1787 VSS.n803 VSS.n469 5.2005
R1788 VSS.n892 VSS.n891 5.2005
R1789 VSS.n891 VSS.n890 5.2005
R1790 VSS.n808 VSS.n692 5.2005
R1791 VSS.n889 VSS.n692 5.2005
R1792 VSS.n887 VSS.n886 5.2005
R1793 VSS.n888 VSS.n887 5.2005
R1794 VSS.n815 VSS.n805 5.2005
R1795 VSS.n805 VSS.n804 5.2005
R1796 VSS.n880 VSS.n817 5.2005
R1797 VSS.n834 VSS.n817 5.2005
R1798 VSS.n877 VSS.n818 5.2005
R1799 VSS.n835 VSS.n818 5.2005
R1800 VSS.n875 VSS.n819 5.2005
R1801 VSS.n836 VSS.n819 5.2005
R1802 VSS.n838 VSS.n825 5.2005
R1803 VSS.n838 VSS.n837 5.2005
R1804 VSS.n870 VSS.n869 5.2005
R1805 VSS.n871 VSS.n870 5.2005
R1806 VSS.n823 VSS.n822 5.2005
R1807 VSS.n867 VSS.n866 5.2005
R1808 VSS.n865 VSS.n833 5.2005
R1809 VSS.n864 VSS.n863 5.2005
R1810 VSS.n862 VSS.n861 5.2005
R1811 VSS.n860 VSS.n859 5.2005
R1812 VSS.n858 VSS.n857 5.2005
R1813 VSS.n856 VSS.n855 5.2005
R1814 VSS.n854 VSS.n853 5.2005
R1815 VSS.n852 VSS.n851 5.2005
R1816 VSS.n850 VSS.n849 5.2005
R1817 VSS.n848 VSS.n847 5.2005
R1818 VSS.n846 VSS.n845 5.2005
R1819 VSS.n844 VSS.n843 5.2005
R1820 VSS.n842 VSS.n841 5.2005
R1821 VSS.n840 VSS.n839 5.2005
R1822 VSS.n731 VSS.n730 5.2005
R1823 VSS.n732 VSS.n727 5.2005
R1824 VSS.n734 VSS.n733 5.2005
R1825 VSS.n736 VSS.n725 5.2005
R1826 VSS.n738 VSS.n737 5.2005
R1827 VSS.n739 VSS.n724 5.2005
R1828 VSS.n741 VSS.n379 5.2005
R1829 VSS.n741 VSS.n740 5.2005
R1830 VSS.n742 VSS.n723 5.2005
R1831 VSS.n745 VSS.n744 5.2005
R1832 VSS.n722 VSS.n379 5.2005
R1833 VSS.n746 VSS.n722 5.2005
R1834 VSS.n748 VSS.n747 5.2005
R1835 VSS.n750 VSS.n720 5.2005
R1836 VSS.n752 VSS.n751 5.2005
R1837 VSS.n753 VSS.n719 5.2005
R1838 VSS.n755 VSS.n379 5.2005
R1839 VSS.n755 VSS.n754 5.2005
R1840 VSS.n756 VSS.n718 5.2005
R1841 VSS.n759 VSS.n758 5.2005
R1842 VSS.n717 VSS.n711 5.2005
R1843 VSS.n760 VSS.n717 5.2005
R1844 VSS.n763 VSS.n762 5.2005
R1845 VSS.n762 VSS.n761 5.2005
R1846 VSS.n712 VSS.n706 5.2005
R1847 VSS.n706 VSS.n705 5.2005
R1848 VSS.n780 VSS.n779 5.2005
R1849 VSS.n781 VSS.n780 5.2005
R1850 VSS.n769 VSS.n704 5.2005
R1851 VSS.n782 VSS.n704 5.2005
R1852 VSS.t230 VSS.n784 5.2005
R1853 VSS.n784 VSS.n783 5.2005
R1854 VSS.n770 VSS.n700 5.2005
R1855 VSS.n700 VSS.n699 5.2005
R1856 VSS.n791 VSS.n790 5.2005
R1857 VSS.n792 VSS.n791 5.2005
R1858 VSS.n698 VSS.n697 5.2005
R1859 VSS.n793 VSS.n698 5.2005
R1860 VSS.n796 VSS.n795 5.2005
R1861 VSS.n795 VSS.n794 5.2005
R1862 VSS.n950 VSS.n497 5.2005
R1863 VSS.n689 VSS.n497 5.2005
R1864 VSS.n899 VSS.n898 5.2005
R1865 VSS.n898 VSS.n897 5.2005
R1866 VSS.n688 VSS.n399 5.2005
R1867 VSS.n896 VSS.n688 5.2005
R1868 VSS.n990 VSS.n471 5.2005
R1869 VSS.n895 VSS.n471 5.2005
R1870 VSS.n893 VSS.n892 5.2005
R1871 VSS.n894 VSS.n893 5.2005
R1872 VSS.n808 VSS.n691 5.2005
R1873 VSS.n691 VSS.n690 5.2005
R1874 VSS.n886 VSS.n885 5.2005
R1875 VSS.n885 VSS.n884 5.2005
R1876 VSS.n815 VSS.n811 5.2005
R1877 VSS.n883 VSS.n811 5.2005
R1878 VSS.n881 VSS.n880 5.2005
R1879 VSS.n882 VSS.n881 5.2005
R1880 VSS.n877 VSS.n813 5.2005
R1881 VSS.n813 VSS.n812 5.2005
R1882 VSS.n875 VSS.n874 5.2005
R1883 VSS.n874 VSS.n873 5.2005
R1884 VSS.n825 VSS.n821 5.2005
R1885 VSS.n872 VSS.n821 5.2005
R1886 VSS.t109 VSS.n491 4.62804
R1887 VSS.t197 VSS.n1254 4.62804
R1888 VSS.n21 VSS.n20 4.52836
R1889 VSS.n19 VSS.n17 4.52836
R1890 VSS.n27 VSS.n26 4.52836
R1891 VSS.n16 VSS.n14 4.52836
R1892 VSS.n35 VSS.n34 4.52836
R1893 VSS.n38 VSS.n37 4.52836
R1894 VSS.n44 VSS.n43 4.52836
R1895 VSS.n46 VSS.n45 4.52836
R1896 VSS.n1133 VSS.n1132 4.52836
R1897 VSS.n1170 VSS.n1131 4.52836
R1898 VSS.n1166 VSS.n1130 4.52836
R1899 VSS.n1162 VSS.n1129 4.52836
R1900 VSS.n1158 VSS.n1128 4.52836
R1901 VSS.n1154 VSS.n1127 4.52836
R1902 VSS.n1150 VSS.n1126 4.52836
R1903 VSS.n1146 VSS.n1125 4.52836
R1904 VSS.n20 VSS.n4 4.52836
R1905 VSS.n22 VSS.n19 4.52836
R1906 VSS.n28 VSS.n27 4.52836
R1907 VSS.n29 VSS.n16 4.52836
R1908 VSS.n34 VSS.n33 4.52836
R1909 VSS.n37 VSS.n36 4.52836
R1910 VSS.n43 VSS.n42 4.52836
R1911 VSS.n45 VSS.n8 4.52836
R1912 VSS.n1143 VSS.n1125 4.52836
R1913 VSS.n1147 VSS.n1126 4.52836
R1914 VSS.n1151 VSS.n1127 4.52836
R1915 VSS.n1155 VSS.n1128 4.52836
R1916 VSS.n1159 VSS.n1129 4.52836
R1917 VSS.n1163 VSS.n1130 4.52836
R1918 VSS.n1167 VSS.n1131 4.52836
R1919 VSS.n1171 VSS.n1132 4.52836
R1920 VSS.n868 VSS.n823 4.52836
R1921 VSS.n833 VSS.n832 4.52836
R1922 VSS.n862 VSS.n831 4.52836
R1923 VSS.n858 VSS.n830 4.52836
R1924 VSS.n854 VSS.n829 4.52836
R1925 VSS.n850 VSS.n828 4.52836
R1926 VSS.n846 VSS.n827 4.52836
R1927 VSS.n842 VSS.n826 4.52836
R1928 VSS.n729 VSS.n727 4.52836
R1929 VSS.n736 VSS.n735 4.52836
R1930 VSS.n726 VSS.n724 4.52836
R1931 VSS.n744 VSS.n743 4.52836
R1932 VSS.n750 VSS.n749 4.52836
R1933 VSS.n721 VSS.n719 4.52836
R1934 VSS.n757 VSS.n756 4.52836
R1935 VSS.n730 VSS.n729 4.52836
R1936 VSS.n735 VSS.n734 4.52836
R1937 VSS.n737 VSS.n726 4.52836
R1938 VSS.n743 VSS.n742 4.52836
R1939 VSS.n749 VSS.n748 4.52836
R1940 VSS.n751 VSS.n721 4.52836
R1941 VSS.n758 VSS.n757 4.52836
R1942 VSS.n839 VSS.n826 4.52836
R1943 VSS.n843 VSS.n827 4.52836
R1944 VSS.n847 VSS.n828 4.52836
R1945 VSS.n851 VSS.n829 4.52836
R1946 VSS.n855 VSS.n830 4.52836
R1947 VSS.n859 VSS.n831 4.52836
R1948 VSS.n863 VSS.n832 4.52836
R1949 VSS.n868 VSS.n867 4.52836
R1950 VSS.t158 VSS.n399 4.51517
R1951 VSS.t164 VSS.t158 4.51517
R1952 VSS.t160 VSS.t166 4.51517
R1953 VSS.t16 VSS.t17 4.51517
R1954 VSS.t220 VSS.t15 4.51517
R1955 VSS.t183 VSS.t181 4.51517
R1956 VSS.t187 VSS.t185 4.51517
R1957 VSS.t229 VSS.t132 4.51517
R1958 VSS.t217 VSS.t145 4.51517
R1959 VSS.t68 VSS.t70 4.51517
R1960 VSS.t72 VSS.t66 4.51517
R1961 VSS.n1203 VSS.t84 4.51517
R1962 VSS.t84 VSS.t87 4.51517
R1963 VSS.t89 VSS.t92 4.51517
R1964 VSS.n957 VSS.n485 4.40231
R1965 VSS.t178 VSS.n394 4.40231
R1966 VSS.n624 VSS.t82 4.40231
R1967 VSS.n950 VSS.n491 4.40231
R1968 VSS.n796 VSS.n545 4.40231
R1969 VSS.n790 VSS.n515 4.40231
R1970 VSS.n779 VSS.n707 4.40231
R1971 VSS.n1309 VSS.n196 4.40231
R1972 VSS.t6 VSS.n207 4.40231
R1973 VSS.t236 VSS.n107 4.40231
R1974 VSS.n1254 VSS.n1253 4.40231
R1975 VSS.n1210 VSS.n94 4.40231
R1976 VSS.n1418 VSS.n58 4.40231
R1977 VSS.n1427 VSS.n55 4.40231
R1978 VSS.n1075 VSS.n377 4.34122
R1979 VSS.n383 VSS.n382 4.34122
R1980 VSS.n1069 VSS.n381 4.34122
R1981 VSS.n1065 VSS.n380 4.34122
R1982 VSS.n1103 VSS.n349 4.34122
R1983 VSS.n1115 VSS.n348 4.34122
R1984 VSS.n1118 VSS.n347 4.34122
R1985 VSS.n1123 VSS.n352 4.34122
R1986 VSS.n444 VSS.n443 4.34122
R1987 VSS.n451 VSS.n450 4.34122
R1988 VSS.n454 VSS.n453 4.34122
R1989 VSS.n459 VSS.n458 4.34122
R1990 VSS.n920 VSS.n531 4.34122
R1991 VSS.n924 VSS.n532 4.34122
R1992 VSS.n927 VSS.n533 4.34122
R1993 VSS.n935 VSS.n535 4.34122
R1994 VSS.n160 VSS.n159 4.34122
R1995 VSS.n167 VSS.n166 4.34122
R1996 VSS.n170 VSS.n169 4.34122
R1997 VSS.n175 VSS.n174 4.34122
R1998 VSS.n1402 VSS.n60 4.34122
R1999 VSS.n1406 VSS.n59 4.34122
R2000 VSS.n1407 VSS.n78 4.34122
R2001 VSS.n1416 VSS.n79 4.34122
R2002 VSS.n1010 VSS.n1009 4.34122
R2003 VSS.n1007 VSS.n1006 4.34122
R2004 VSS.n430 VSS.n428 4.34122
R2005 VSS.n1000 VSS.n999 4.34122
R2006 VSS.n644 VSS.n518 4.34122
R2007 VSS.n640 VSS.n517 4.34122
R2008 VSS.n636 VSS.n516 4.34122
R2009 VSS.n937 VSS.n514 4.34122
R2010 VSS.n1364 VSS.n1363 4.34122
R2011 VSS.n1361 VSS.n1360 4.34122
R2012 VSS.n146 VSS.n144 4.34122
R2013 VSS.n1354 VSS.n1353 4.34122
R2014 VSS.n254 VSS.n64 4.34122
R2015 VSS.n249 VSS.n63 4.34122
R2016 VSS.n245 VSS.n62 4.34122
R2017 VSS.n239 VSS.n61 4.34122
R2018 VSS.n984 VSS.n983 4.34122
R2019 VSS.n477 VSS.n475 4.34122
R2020 VSS.n975 VSS.n974 4.34122
R2021 VSS.n964 VSS.n478 4.34122
R2022 VSS.n563 VSS.n527 4.34122
R2023 VSS.n559 VSS.n528 4.34122
R2024 VSS.n555 VSS.n529 4.34122
R2025 VSS.n549 VSS.n530 4.34122
R2026 VSS.n1337 VSS.n1336 4.34122
R2027 VSS.n1316 VSS.n1314 4.34122
R2028 VSS.n1328 VSS.n1327 4.34122
R2029 VSS.n1319 VSS.n1318 4.34122
R2030 VSS.n284 VSS.n73 4.34122
R2031 VSS.n279 VSS.n74 4.34122
R2032 VSS.n275 VSS.n75 4.34122
R2033 VSS.n269 VSS.n76 4.34122
R2034 VSS.n599 VSS.n598 4.34122
R2035 VSS.n577 VSS.n575 4.34122
R2036 VSS.n590 VSS.n589 4.34122
R2037 VSS.n579 VSS.n578 4.34122
R2038 VSS.n674 VSS.n523 4.34122
R2039 VSS.n670 VSS.n522 4.34122
R2040 VSS.n666 VSS.n521 4.34122
R2041 VSS.n660 VSS.n520 4.34122
R2042 VSS.n1301 VSS.n1300 4.34122
R2043 VSS.n201 VSS.n199 4.34122
R2044 VSS.n1292 VSS.n1291 4.34122
R2045 VSS.n1281 VSS.n202 4.34122
R2046 VSS.n1222 VSS.n69 4.34122
R2047 VSS.n1228 VSS.n68 4.34122
R2048 VSS.n1232 VSS.n67 4.34122
R2049 VSS.n1238 VSS.n66 4.34122
R2050 VSS.n1227 VSS.n69 4.34122
R2051 VSS.n1231 VSS.n68 4.34122
R2052 VSS.n1237 VSS.n67 4.34122
R2053 VSS.n1240 VSS.n66 4.34122
R2054 VSS.n1282 VSS.n1281 4.34122
R2055 VSS.n1291 VSS.n1290 4.34122
R2056 VSS.n1293 VSS.n201 4.34122
R2057 VSS.n1300 VSS.n1299 4.34122
R2058 VSS.n671 VSS.n523 4.34122
R2059 VSS.n667 VSS.n522 4.34122
R2060 VSS.n661 VSS.n521 4.34122
R2061 VSS.n657 VSS.n520 4.34122
R2062 VSS.n580 VSS.n579 4.34122
R2063 VSS.n589 VSS.n588 4.34122
R2064 VSS.n591 VSS.n577 4.34122
R2065 VSS.n598 VSS.n597 4.34122
R2066 VSS.n280 VSS.n73 4.34122
R2067 VSS.n276 VSS.n74 4.34122
R2068 VSS.n270 VSS.n75 4.34122
R2069 VSS.n266 VSS.n76 4.34122
R2070 VSS.n1318 VSS.n1317 4.34122
R2071 VSS.n1327 VSS.n1326 4.34122
R2072 VSS.n1329 VSS.n1316 4.34122
R2073 VSS.n1336 VSS.n1335 4.34122
R2074 VSS.n560 VSS.n527 4.34122
R2075 VSS.n556 VSS.n528 4.34122
R2076 VSS.n550 VSS.n529 4.34122
R2077 VSS.n542 VSS.n530 4.34122
R2078 VSS.n965 VSS.n964 4.34122
R2079 VSS.n974 VSS.n973 4.34122
R2080 VSS.n976 VSS.n477 4.34122
R2081 VSS.n983 VSS.n982 4.34122
R2082 VSS.n250 VSS.n64 4.34122
R2083 VSS.n246 VSS.n63 4.34122
R2084 VSS.n240 VSS.n62 4.34122
R2085 VSS.n89 VSS.n61 4.34122
R2086 VSS.n1353 VSS.n1352 4.34122
R2087 VSS.n1355 VSS.n146 4.34122
R2088 VSS.n1360 VSS.n1359 4.34122
R2089 VSS.n1363 VSS.n1362 4.34122
R2090 VSS.n641 VSS.n518 4.34122
R2091 VSS.n637 VSS.n517 4.34122
R2092 VSS.n631 VSS.n516 4.34122
R2093 VSS.n938 VSS.n937 4.34122
R2094 VSS.n999 VSS.n998 4.34122
R2095 VSS.n1001 VSS.n430 4.34122
R2096 VSS.n1006 VSS.n1005 4.34122
R2097 VSS.n1009 VSS.n1008 4.34122
R2098 VSS.n1397 VSS.n60 4.34122
R2099 VSS.n1403 VSS.n59 4.34122
R2100 VSS.n1411 VSS.n78 4.34122
R2101 VSS.n1416 VSS.n1415 4.34122
R2102 VSS.n176 VSS.n175 4.34122
R2103 VSS.n169 VSS.n156 4.34122
R2104 VSS.n168 VSS.n167 4.34122
R2105 VSS.n159 VSS.n158 4.34122
R2106 VSS.n917 VSS.n531 4.34122
R2107 VSS.n921 VSS.n532 4.34122
R2108 VSS.n925 VSS.n533 4.34122
R2109 VSS.n935 VSS.n934 4.34122
R2110 VSS.n460 VSS.n459 4.34122
R2111 VSS.n453 VSS.n440 4.34122
R2112 VSS.n452 VSS.n451 4.34122
R2113 VSS.n443 VSS.n442 4.34122
R2114 VSS.n1105 VSS.n349 4.34122
R2115 VSS.n1112 VSS.n348 4.34122
R2116 VSS.n1116 VSS.n347 4.34122
R2117 VSS.n1123 VSS.n1122 4.34122
R2118 VSS.n1058 VSS.n380 4.34122
R2119 VSS.n1066 VSS.n381 4.34122
R2120 VSS.n1070 VSS.n382 4.34122
R2121 VSS.n1075 VSS.n1074 4.34122
R2122 VSS.n892 VSS.n417 4.06371
R2123 VSS.n1197 VSS.n135 4.06371
R2124 VSS.n876 VSS.t44 3.95771
R2125 VSS.n816 VSS.t194 3.95771
R2126 VSS.n809 VSS.t105 3.95771
R2127 VSS.n344 VSS.t54 3.95771
R2128 VSS.n1187 VSS.t136 3.95771
R2129 VSS.n336 VSS.t119 3.95771
R2130 VSS.n1030 VSS.n1029 3.72542
R2131 VSS.n1027 VSS.n1026 3.72542
R2132 VSS.n616 VSS.n615 3.72542
R2133 VSS.n618 VSS.n617 3.72542
R2134 VSS.n1269 VSS.n1268 3.72542
R2135 VSS.n1266 VSS.n1265 3.72542
R2136 VSS.n218 VSS.n217 3.72542
R2137 VSS.n216 VSS.n215 3.72542
R2138 VSS.n217 VSS.n211 3.72542
R2139 VSS.n215 VSS.n214 3.72542
R2140 VSS.n1265 VSS.n1264 3.72542
R2141 VSS.n1268 VSS.n1267 3.72542
R2142 VSS.n615 VSS.n614 3.72542
R2143 VSS.n619 VSS.n618 3.72542
R2144 VSS.n1026 VSS.n1025 3.72542
R2145 VSS.n1029 VSS.n1028 3.72542
R2146 VSS.n1049 VSS.n1048 3.59234
R2147 VSS.n1084 VSS.n1083 3.59234
R2148 VSS.n1083 VSS.t232 3.49937
R2149 VSS.n1048 VSS.t10 3.49937
R2150 VSS.n364 VSS.t127 3.49937
R2151 VSS.t19 VSS.n362 3.49937
R2152 VSS.n362 VSS.n358 3.49549
R2153 VSS.n365 VSS.n364 3.49549
R2154 VSS.n892 VSS.n424 3.3865
R2155 VSS.n1022 VSS.n399 3.3865
R2156 VSS.n790 VSS.t28 3.3865
R2157 VSS.n779 VSS.t216 3.3865
R2158 VSS.n1197 VSS.n140 3.3865
R2159 VSS.n1203 VSS.n120 3.3865
R2160 VSS.n58 VSS.t154 3.3865
R2161 VSS.t151 VSS.n55 3.3865
R2162 VSS.n1015 VSS.t141 2.82217
R2163 VSS.n915 VSS.t209 2.82217
R2164 VSS.n770 VSS.t214 2.82217
R2165 VSS.t222 VSS.n769 2.82217
R2166 VSS.n1369 VSS.t122 2.82217
R2167 VSS.n1393 VSS.t120 2.82217
R2168 VSS.n57 VSS.t41 2.82217
R2169 VSS.t228 VSS.n56 2.82217
R2170 VSS.t142 VSS.t146 2.25784
R2171 VSS.t146 VSS.t143 2.25784
R2172 VSS.t64 VSS.t193 2.25784
R2173 VSS.t193 VSS.t65 2.25784
R2174 VSS.t124 VSS.t123 2.25784
R2175 VSS.t123 VSS.t125 2.25784
R2176 VSS.t59 VSS.t62 2.25784
R2177 VSS.t63 VSS.t59 2.25784
R2178 VSS.t47 VSS.t55 2.25784
R2179 VSS.t56 VSS.t47 2.25784
R2180 VSS.t4 VSS.t30 2.25784
R2181 VSS.t23 VSS.t4 2.25784
R2182 VSS.n484 VSS.t164 2.25784
R2183 VSS.t166 VSS.n484 2.25784
R2184 VSS.n610 VSS.t109 2.25784
R2185 VSS.n610 VSS.t113 2.25784
R2186 VSS.t34 VSS.t5 2.25784
R2187 VSS.t5 VSS.t22 2.25784
R2188 VSS.t60 VSS.t3 2.25784
R2189 VSS.t3 VSS.t61 2.25784
R2190 VSS.t144 VSS.t28 2.25784
R2191 VSS.t29 VSS.t144 2.25784
R2192 VSS.t230 VSS.t75 2.25784
R2193 VSS.t230 VSS.t76 2.25784
R2194 VSS.t126 VSS.t215 2.25784
R2195 VSS.t216 VSS.t126 2.25784
R2196 VSS.t106 VSS.t25 2.25784
R2197 VSS.t25 VSS.t107 2.25784
R2198 VSS.t14 VSS.n1085 2.25784
R2199 VSS.t181 VSS.t220 2.25784
R2200 VSS.n1086 VSS.t183 2.25784
R2201 VSS.n1086 VSS.t185 2.25784
R2202 VSS.t132 VSS.t187 2.25784
R2203 VSS.n1050 VSS.t133 2.25784
R2204 VSS.n1094 VSS.t235 2.25784
R2205 VSS.t127 VSS.t68 2.25784
R2206 VSS.t70 VSS.n363 2.25784
R2207 VSS.n363 VSS.t72 2.25784
R2208 VSS.t66 VSS.t19 2.25784
R2209 VSS.n1100 VSS.t147 2.25784
R2210 VSS.t57 VSS.t156 2.25784
R2211 VSS.t156 VSS.t58 2.25784
R2212 VSS.t77 VSS.t221 2.25784
R2213 VSS.t221 VSS.t78 2.25784
R2214 VSS.t152 VSS.t192 2.25784
R2215 VSS.t192 VSS.t153 2.25784
R2216 VSS.t234 VSS.t39 2.25784
R2217 VSS.t40 VSS.t234 2.25784
R2218 VSS.t238 VSS.t0 2.25784
R2219 VSS.t1 VSS.t238 2.25784
R2220 VSS.t26 VSS.t24 2.25784
R2221 VSS.t8 VSS.t26 2.25784
R2222 VSS.t87 VSS.n300 2.25784
R2223 VSS.n300 VSS.t89 2.25784
R2224 VSS.n1255 VSS.t197 2.25784
R2225 VSS.n1255 VSS.t195 2.25784
R2226 VSS.t33 VSS.t11 2.25784
R2227 VSS.t11 VSS.t20 2.25784
R2228 VSS.t212 VSS.t189 2.25784
R2229 VSS.t189 VSS.t213 2.25784
R2230 VSS.t154 VSS.t207 2.25784
R2231 VSS.t207 VSS.t155 2.25784
R2232 VSS.t223 VSS.t139 2.25784
R2233 VSS.t223 VSS.t140 2.25784
R2234 VSS.t150 VSS.t208 2.25784
R2235 VSS.t208 VSS.t151 2.25784
R2236 VSS.t157 VSS.t79 2.25784
R2237 VSS.t80 VSS.t157 2.25784
R2238 VSS.t55 VSS.n463 2.14497
R2239 VSS.n464 VSS.t23 2.14497
R2240 VSS.n696 VSS.t34 2.14497
R2241 VSS.t61 VSS.n695 2.14497
R2242 VSS.t0 VSS.n181 2.14497
R2243 VSS.n182 VSS.t8 2.14497
R2244 VSS.n1211 VSS.t33 2.14497
R2245 VSS.t213 VSS.n295 2.14497
R2246 VSS.n697 VSS.n504 1.58064
R2247 VSS.n714 VSS.n712 1.58064
R2248 VSS.n321 VSS.n237 1.58064
R2249 VSS.n1429 VSS.n53 1.58064
R2250 VSS.n875 VSS.n820 1.24204
R2251 VSS.n990 VSS.n465 1.24204
R2252 VSS.n796 VSS.n696 1.24204
R2253 VSS.n943 VSS.n509 1.24204
R2254 VSS.n763 VSS.n716 1.24204
R2255 VSS.n1085 VSS.n1084 1.24204
R2256 VSS.n1050 VSS.n1049 1.24204
R2257 VSS.n1094 VSS.n365 1.24204
R2258 VSS.n1100 VSS.n358 1.24204
R2259 VSS.n1180 VSS.n1179 1.24204
R2260 VSS.n1343 VSS.n183 1.24204
R2261 VSS.n1211 VSS.n1210 1.24204
R2262 VSS.n1247 VSS.n1212 1.24204
R2263 VSS.n51 VSS.n7 1.24204
R2264 VSS.t30 VSS.t56 1.12917
R2265 VSS.t22 VSS.t60 1.12917
R2266 VSS.t24 VSS.t1 1.12917
R2267 VSS.t20 VSS.t212 1.12917
R2268 VSS.n1083 VSS.t46 1.0163
R2269 VSS.n1084 VSS.t45 1.0163
R2270 VSS.n1049 VSS.t121 1.0163
R2271 VSS.n1048 VSS.t9 1.0163
R2272 VSS.n365 VSS.t108 1.0163
R2273 VSS.n364 VSS.t233 1.0163
R2274 VSS.n362 VSS.t18 1.0163
R2275 VSS.t231 VSS.n358 1.0163
R2276 VSS.n18 VSS.n2 0.9005
R2277 VSS.n23 VSS.n18 0.9005
R2278 VSS.n24 VSS.n23 0.9005
R2279 VSS.n25 VSS.n24 0.9005
R2280 VSS.n25 VSS.n15 0.9005
R2281 VSS.n30 VSS.n15 0.9005
R2282 VSS.n31 VSS.n30 0.9005
R2283 VSS.n32 VSS.n31 0.9005
R2284 VSS.n32 VSS.n13 0.9005
R2285 VSS.n13 VSS.n12 0.9005
R2286 VSS.n39 VSS.n12 0.9005
R2287 VSS.n40 VSS.n39 0.9005
R2288 VSS.n41 VSS.n40 0.9005
R2289 VSS.n41 VSS.n10 0.9005
R2290 VSS.n47 VSS.n10 0.9005
R2291 VSS.n48 VSS.n47 0.9005
R2292 VSS.n1142 VSS.n1141 0.9005
R2293 VSS.n1141 VSS.n1140 0.9005
R2294 VSS.n1140 VSS.n1136 0.9005
R2295 VSS.n1136 VSS.n1135 0.9005
R2296 VSS.n1135 VSS.n1134 0.9005
R2297 VSS.n1134 VSS.n327 0.9005
R2298 VSS.n1199 VSS.n327 0.9005
R2299 VSS.n1200 VSS.n1199 0.9005
R2300 VSS.n1201 VSS.n1200 0.9005
R2301 VSS.n1201 VSS.n326 0.9005
R2302 VSS.n326 VSS.n325 0.9005
R2303 VSS.n325 VSS.n324 0.9005
R2304 VSS.n324 VSS.n323 0.9005
R2305 VSS.n323 VSS.n302 0.9005
R2306 VSS.n318 VSS.n302 0.9005
R2307 VSS.n318 VSS.n317 0.9005
R2308 VSS.n317 VSS.n316 0.9005
R2309 VSS.n316 VSS.n313 0.9005
R2310 VSS.n313 VSS.n312 0.9005
R2311 VSS.n312 VSS.n3 0.9005
R2312 VSS.n1145 VSS.n1144 0.9005
R2313 VSS.n1148 VSS.n1145 0.9005
R2314 VSS.n1149 VSS.n1148 0.9005
R2315 VSS.n1152 VSS.n1149 0.9005
R2316 VSS.n1153 VSS.n1152 0.9005
R2317 VSS.n1156 VSS.n1153 0.9005
R2318 VSS.n1157 VSS.n1156 0.9005
R2319 VSS.n1160 VSS.n1157 0.9005
R2320 VSS.n1161 VSS.n1160 0.9005
R2321 VSS.n1164 VSS.n1161 0.9005
R2322 VSS.n1165 VSS.n1164 0.9005
R2323 VSS.n1168 VSS.n1165 0.9005
R2324 VSS.n1169 VSS.n1168 0.9005
R2325 VSS.n1172 VSS.n1169 0.9005
R2326 VSS.n1173 VSS.n1172 0.9005
R2327 VSS.n1174 VSS.n1173 0.9005
R2328 VSS.n1182 VSS.n342 0.9005
R2329 VSS.n1183 VSS.n1182 0.9005
R2330 VSS.n1184 VSS.n1183 0.9005
R2331 VSS.n1184 VSS.n331 0.9005
R2332 VSS.n1193 VSS.n331 0.9005
R2333 VSS.n1194 VSS.n1193 0.9005
R2334 VSS.n1195 VSS.n1194 0.9005
R2335 VSS.n1195 VSS.n330 0.9005
R2336 VSS.n330 VSS.n299 0.9005
R2337 VSS.n1206 VSS.n299 0.9005
R2338 VSS.n1207 VSS.n1206 0.9005
R2339 VSS.n1208 VSS.n1207 0.9005
R2340 VSS.n1208 VSS.n298 0.9005
R2341 VSS.n307 VSS.n298 0.9005
R2342 VSS.n308 VSS.n307 0.9005
R2343 VSS.n309 VSS.n308 0.9005
R2344 VSS.n309 VSS.n305 0.9005
R2345 VSS.n305 VSS.n49 0.9005
R2346 VSS.n1431 VSS.n49 0.9005
R2347 VSS.n1432 VSS.n1431 0.9005
R2348 VSS.n873 VSS.n872 0.9005
R2349 VSS.n873 VSS.n812 0.9005
R2350 VSS.n882 VSS.n812 0.9005
R2351 VSS.n883 VSS.n882 0.9005
R2352 VSS.n884 VSS.n883 0.9005
R2353 VSS.n884 VSS.n690 0.9005
R2354 VSS.n894 VSS.n690 0.9005
R2355 VSS.n895 VSS.n894 0.9005
R2356 VSS.n896 VSS.n895 0.9005
R2357 VSS.n897 VSS.n896 0.9005
R2358 VSS.n897 VSS.n689 0.9005
R2359 VSS.n794 VSS.n689 0.9005
R2360 VSS.n794 VSS.n793 0.9005
R2361 VSS.n793 VSS.n792 0.9005
R2362 VSS.n792 VSS.n699 0.9005
R2363 VSS.n783 VSS.n699 0.9005
R2364 VSS.n783 VSS.n782 0.9005
R2365 VSS.n782 VSS.n781 0.9005
R2366 VSS.n781 VSS.n705 0.9005
R2367 VSS.n761 VSS.n705 0.9005
R2368 VSS.n732 VSS.n731 0.9005
R2369 VSS.n733 VSS.n732 0.9005
R2370 VSS.n733 VSS.n725 0.9005
R2371 VSS.n738 VSS.n725 0.9005
R2372 VSS.n739 VSS.n738 0.9005
R2373 VSS.n740 VSS.n739 0.9005
R2374 VSS.n740 VSS.n723 0.9005
R2375 VSS.n745 VSS.n723 0.9005
R2376 VSS.n746 VSS.n745 0.9005
R2377 VSS.n747 VSS.n746 0.9005
R2378 VSS.n747 VSS.n720 0.9005
R2379 VSS.n752 VSS.n720 0.9005
R2380 VSS.n753 VSS.n752 0.9005
R2381 VSS.n754 VSS.n753 0.9005
R2382 VSS.n754 VSS.n718 0.9005
R2383 VSS.n759 VSS.n718 0.9005
R2384 VSS.n837 VSS.n836 0.9005
R2385 VSS.n836 VSS.n835 0.9005
R2386 VSS.n835 VSS.n834 0.9005
R2387 VSS.n834 VSS.n804 0.9005
R2388 VSS.n888 VSS.n804 0.9005
R2389 VSS.n889 VSS.n888 0.9005
R2390 VSS.n890 VSS.n889 0.9005
R2391 VSS.n890 VSS.n803 0.9005
R2392 VSS.n803 VSS.n802 0.9005
R2393 VSS.n802 VSS.n800 0.9005
R2394 VSS.n800 VSS.n799 0.9005
R2395 VSS.n799 VSS.n798 0.9005
R2396 VSS.n798 VSS.n693 0.9005
R2397 VSS.n788 VSS.n693 0.9005
R2398 VSS.n788 VSS.n787 0.9005
R2399 VSS.n787 VSS.n786 0.9005
R2400 VSS.n786 VSS.n702 0.9005
R2401 VSS.n767 VSS.n702 0.9005
R2402 VSS.n767 VSS.n766 0.9005
R2403 VSS.n766 VSS.n765 0.9005
R2404 VSS.n841 VSS.n840 0.9005
R2405 VSS.n844 VSS.n841 0.9005
R2406 VSS.n845 VSS.n844 0.9005
R2407 VSS.n848 VSS.n845 0.9005
R2408 VSS.n849 VSS.n848 0.9005
R2409 VSS.n852 VSS.n849 0.9005
R2410 VSS.n853 VSS.n852 0.9005
R2411 VSS.n856 VSS.n853 0.9005
R2412 VSS.n857 VSS.n856 0.9005
R2413 VSS.n860 VSS.n857 0.9005
R2414 VSS.n861 VSS.n860 0.9005
R2415 VSS.n864 VSS.n861 0.9005
R2416 VSS.n865 VSS.n864 0.9005
R2417 VSS.n866 VSS.n865 0.9005
R2418 VSS.n866 VSS.n822 0.9005
R2419 VSS.n871 VSS.n822 0.9005
R2420 VSS.n695 VSS.n545 0.898459
R2421 VSS.n463 VSS.n404 0.898459
R2422 VSS.n295 VSS.n94 0.877945
R2423 VSS.n181 VSS.n125 0.877945
R2424 VSS.n602 VSS.n601 0.7655
R2425 VSS.n658 VSS.n656 0.7655
R2426 VSS.n1013 VSS.n1012 0.7655
R2427 VSS.n940 VSS.n939 0.7655
R2428 VSS.n1017 VSS.n411 0.7655
R2429 VSS.n933 VSS.n502 0.7655
R2430 VSS.n987 VSS.n986 0.7655
R2431 VSS.n913 VSS.n543 0.7655
R2432 VSS.n1367 VSS.n1366 0.7655
R2433 VSS.n1391 VSS.n91 0.7655
R2434 VSS.n1371 VSS.n129 0.7655
R2435 VSS.n1414 VSS.n81 0.7655
R2436 VSS.n1340 VSS.n1339 0.7655
R2437 VSS.n267 VSS.n236 0.7655
R2438 VSS.n1304 VSS.n1303 0.7655
R2439 VSS.n1242 VSS.n1241 0.7655
R2440 VSS.n1029 VSS.n1022 0.73879
R2441 VSS.n1026 VSS.n1022 0.73879
R2442 VSS.n615 VSS.n572 0.73879
R2443 VSS.n618 VSS.n572 0.73879
R2444 VSS.n1268 VSS.n120 0.73879
R2445 VSS.n1265 VSS.n120 0.73879
R2446 VSS.n217 VSS.n99 0.73879
R2447 VSS.n215 VSS.n99 0.73879
R2448 VSS.n1068 VSS.n1067 0.6755
R2449 VSS.n1071 VSS.n1068 0.6755
R2450 VSS.n1072 VSS.n1071 0.6755
R2451 VSS.n1073 VSS.n1072 0.6755
R2452 VSS.n1073 VSS.n376 0.6755
R2453 VSS.n1078 VSS.n376 0.6755
R2454 VSS.n1080 VSS.n1079 0.6755
R2455 VSS.n1080 VSS.n370 0.6755
R2456 VSS.n1088 VSS.n370 0.6755
R2457 VSS.n1089 VSS.n1088 0.6755
R2458 VSS.n1090 VSS.n1089 0.6755
R2459 VSS.n1090 VSS.n360 0.6755
R2460 VSS.n1096 VSS.n360 0.6755
R2461 VSS.n1097 VSS.n1096 0.6755
R2462 VSS.n1098 VSS.n1097 0.6755
R2463 VSS.n1098 VSS.n354 0.6755
R2464 VSS.n1106 VSS.n1104 0.6755
R2465 VSS.n1113 VSS.n1111 0.6755
R2466 VSS.n1114 VSS.n1113 0.6755
R2467 VSS.n1117 VSS.n1114 0.6755
R2468 VSS.n1119 VSS.n1117 0.6755
R2469 VSS.n1120 VSS.n1119 0.6755
R2470 VSS.n1121 VSS.n1120 0.6755
R2471 VSS.n1056 VSS.n1055 0.6755
R2472 VSS.n1055 VSS.n1054 0.6755
R2473 VSS.n1054 VSS.n1053 0.6755
R2474 VSS.n1053 VSS.n1052 0.6755
R2475 VSS.n1052 VSS.n1047 0.6755
R2476 VSS.n1047 VSS.n1046 0.6755
R2477 VSS.n1046 VSS.n1045 0.6755
R2478 VSS.n1045 VSS.n1044 0.6755
R2479 VSS.n1044 VSS.n357 0.6755
R2480 VSS.n357 VSS.n355 0.6755
R2481 VSS.n587 VSS.n586 0.6755
R2482 VSS.n587 VSS.n576 0.6755
R2483 VSS.n592 VSS.n576 0.6755
R2484 VSS.n593 VSS.n592 0.6755
R2485 VSS.n596 VSS.n574 0.6755
R2486 VSS.n601 VSS.n574 0.6755
R2487 VSS.n603 VSS.n602 0.6755
R2488 VSS.n604 VSS.n603 0.6755
R2489 VSS.n605 VSS.n604 0.6755
R2490 VSS.n905 VSS.n605 0.6755
R2491 VSS.n906 VSS.n905 0.6755
R2492 VSS.n907 VSS.n906 0.6755
R2493 VSS.n907 VSS.n573 0.6755
R2494 VSS.n656 VSS.n573 0.6755
R2495 VSS.n676 VSS.n675 0.6755
R2496 VSS.n675 VSS.n672 0.6755
R2497 VSS.n672 VSS.n669 0.6755
R2498 VSS.n669 VSS.n668 0.6755
R2499 VSS.n668 VSS.n665 0.6755
R2500 VSS.n662 VSS.n659 0.6755
R2501 VSS.n659 VSS.n658 0.6755
R2502 VSS.n682 VSS.n681 0.6755
R2503 VSS.n683 VSS.n682 0.6755
R2504 VSS.n684 VSS.n683 0.6755
R2505 VSS.n685 VSS.n684 0.6755
R2506 VSS.n685 VSS.n680 0.6755
R2507 VSS.n680 VSS.n679 0.6755
R2508 VSS.n679 VSS.n678 0.6755
R2509 VSS.n678 VSS.n677 0.6755
R2510 VSS.n1002 VSS.n429 0.6755
R2511 VSS.n1003 VSS.n1002 0.6755
R2512 VSS.n1004 VSS.n1003 0.6755
R2513 VSS.n1004 VSS.n427 0.6755
R2514 VSS.n1011 VSS.n423 0.6755
R2515 VSS.n1012 VSS.n1011 0.6755
R2516 VSS.n1013 VSS.n422 0.6755
R2517 VSS.n954 VSS.n422 0.6755
R2518 VSS.n955 VSS.n954 0.6755
R2519 VSS.n955 VSS.n953 0.6755
R2520 VSS.n953 VSS.n952 0.6755
R2521 VSS.n952 VSS.n489 0.6755
R2522 VSS.n941 VSS.n489 0.6755
R2523 VSS.n941 VSS.n940 0.6755
R2524 VSS.n646 VSS.n645 0.6755
R2525 VSS.n645 VSS.n642 0.6755
R2526 VSS.n642 VSS.n639 0.6755
R2527 VSS.n639 VSS.n638 0.6755
R2528 VSS.n638 VSS.n635 0.6755
R2529 VSS.n632 VSS.n513 0.6755
R2530 VSS.n939 VSS.n513 0.6755
R2531 VSS.n651 VSS.n435 0.6755
R2532 VSS.n652 VSS.n651 0.6755
R2533 VSS.n653 VSS.n652 0.6755
R2534 VSS.n654 VSS.n653 0.6755
R2535 VSS.n654 VSS.n650 0.6755
R2536 VSS.n650 VSS.n649 0.6755
R2537 VSS.n649 VSS.n648 0.6755
R2538 VSS.n648 VSS.n647 0.6755
R2539 VSS.n457 VSS.n456 0.6755
R2540 VSS.n456 VSS.n455 0.6755
R2541 VSS.n455 VSS.n441 0.6755
R2542 VSS.n449 VSS.n441 0.6755
R2543 VSS.n446 VSS.n445 0.6755
R2544 VSS.n445 VSS.n411 0.6755
R2545 VSS.n1018 VSS.n1017 0.6755
R2546 VSS.n1019 VSS.n1018 0.6755
R2547 VSS.n1019 VSS.n410 0.6755
R2548 VSS.n947 VSS.n410 0.6755
R2549 VSS.n948 VSS.n947 0.6755
R2550 VSS.n948 VSS.n946 0.6755
R2551 VSS.n946 VSS.n945 0.6755
R2552 VSS.n945 VSS.n502 0.6755
R2553 VSS.n919 VSS.n918 0.6755
R2554 VSS.n922 VSS.n919 0.6755
R2555 VSS.n923 VSS.n922 0.6755
R2556 VSS.n926 VSS.n923 0.6755
R2557 VSS.n928 VSS.n926 0.6755
R2558 VSS.n932 VSS.n931 0.6755
R2559 VSS.n933 VSS.n932 0.6755
R2560 VSS.n993 VSS.n992 0.6755
R2561 VSS.n992 VSS.n462 0.6755
R2562 VSS.n628 VSS.n462 0.6755
R2563 VSS.n629 VSS.n628 0.6755
R2564 VSS.n629 VSS.n627 0.6755
R2565 VSS.n627 VSS.n626 0.6755
R2566 VSS.n626 VSS.n625 0.6755
R2567 VSS.n625 VSS.n537 0.6755
R2568 VSS.n972 VSS.n971 0.6755
R2569 VSS.n972 VSS.n476 0.6755
R2570 VSS.n977 VSS.n476 0.6755
R2571 VSS.n978 VSS.n977 0.6755
R2572 VSS.n981 VSS.n474 0.6755
R2573 VSS.n986 VSS.n474 0.6755
R2574 VSS.n988 VSS.n987 0.6755
R2575 VSS.n988 VSS.n473 0.6755
R2576 VSS.n900 VSS.n473 0.6755
R2577 VSS.n901 VSS.n900 0.6755
R2578 VSS.n901 VSS.n544 0.6755
R2579 VSS.n911 VSS.n544 0.6755
R2580 VSS.n912 VSS.n911 0.6755
R2581 VSS.n913 VSS.n912 0.6755
R2582 VSS.n565 VSS.n564 0.6755
R2583 VSS.n564 VSS.n561 0.6755
R2584 VSS.n561 VSS.n558 0.6755
R2585 VSS.n558 VSS.n557 0.6755
R2586 VSS.n557 VSS.n554 0.6755
R2587 VSS.n551 VSS.n548 0.6755
R2588 VSS.n548 VSS.n543 0.6755
R2589 VSS.n962 VSS.n961 0.6755
R2590 VSS.n961 VSS.n960 0.6755
R2591 VSS.n960 VSS.n959 0.6755
R2592 VSS.n959 VSS.n479 0.6755
R2593 VSS.n568 VSS.n479 0.6755
R2594 VSS.n569 VSS.n568 0.6755
R2595 VSS.n569 VSS.n567 0.6755
R2596 VSS.n567 VSS.n566 0.6755
R2597 VSS.n1356 VSS.n145 0.6755
R2598 VSS.n1357 VSS.n1356 0.6755
R2599 VSS.n1358 VSS.n1357 0.6755
R2600 VSS.n1358 VSS.n143 0.6755
R2601 VSS.n1365 VSS.n139 0.6755
R2602 VSS.n1366 VSS.n1365 0.6755
R2603 VSS.n1367 VSS.n118 0.6755
R2604 VSS.n1377 VSS.n118 0.6755
R2605 VSS.n1378 VSS.n1377 0.6755
R2606 VSS.n1379 VSS.n1378 0.6755
R2607 VSS.n1379 VSS.n92 0.6755
R2608 VSS.n1389 VSS.n92 0.6755
R2609 VSS.n1390 VSS.n1389 0.6755
R2610 VSS.n1391 VSS.n1390 0.6755
R2611 VSS.n256 VSS.n255 0.6755
R2612 VSS.n251 VSS.n248 0.6755
R2613 VSS.n248 VSS.n247 0.6755
R2614 VSS.n247 VSS.n244 0.6755
R2615 VSS.n241 VSS.n238 0.6755
R2616 VSS.n238 VSS.n91 0.6755
R2617 VSS.n258 VSS.n151 0.6755
R2618 VSS.n259 VSS.n258 0.6755
R2619 VSS.n260 VSS.n259 0.6755
R2620 VSS.n261 VSS.n260 0.6755
R2621 VSS.n262 VSS.n261 0.6755
R2622 VSS.n263 VSS.n262 0.6755
R2623 VSS.n264 VSS.n263 0.6755
R2624 VSS.n264 VSS.n257 0.6755
R2625 VSS.n173 VSS.n172 0.6755
R2626 VSS.n172 VSS.n171 0.6755
R2627 VSS.n171 VSS.n157 0.6755
R2628 VSS.n165 VSS.n157 0.6755
R2629 VSS.n162 VSS.n161 0.6755
R2630 VSS.n161 VSS.n129 0.6755
R2631 VSS.n1372 VSS.n1371 0.6755
R2632 VSS.n1373 VSS.n1372 0.6755
R2633 VSS.n1373 VSS.n105 0.6755
R2634 VSS.n1383 VSS.n105 0.6755
R2635 VSS.n1384 VSS.n1383 0.6755
R2636 VSS.n1385 VSS.n1384 0.6755
R2637 VSS.n1385 VSS.n104 0.6755
R2638 VSS.n104 VSS.n81 0.6755
R2639 VSS.n1398 VSS.n1396 0.6755
R2640 VSS.n1404 VSS.n1401 0.6755
R2641 VSS.n1405 VSS.n1404 0.6755
R2642 VSS.n1408 VSS.n1405 0.6755
R2643 VSS.n1413 VSS.n1412 0.6755
R2644 VSS.n1414 VSS.n1413 0.6755
R2645 VSS.n224 VSS.n223 0.6755
R2646 VSS.n225 VSS.n224 0.6755
R2647 VSS.n226 VSS.n225 0.6755
R2648 VSS.n227 VSS.n226 0.6755
R2649 VSS.n228 VSS.n227 0.6755
R2650 VSS.n228 VSS.n222 0.6755
R2651 VSS.n222 VSS.n82 0.6755
R2652 VSS.n1395 VSS.n82 0.6755
R2653 VSS.n1325 VSS.n1324 0.6755
R2654 VSS.n1325 VSS.n1315 0.6755
R2655 VSS.n1330 VSS.n1315 0.6755
R2656 VSS.n1331 VSS.n1330 0.6755
R2657 VSS.n1334 VSS.n1313 0.6755
R2658 VSS.n1339 VSS.n1313 0.6755
R2659 VSS.n1341 VSS.n1340 0.6755
R2660 VSS.n1341 VSS.n1312 0.6755
R2661 VSS.n1312 VSS.n1311 0.6755
R2662 VSS.n1311 VSS.n191 0.6755
R2663 VSS.n1251 VSS.n191 0.6755
R2664 VSS.n1251 VSS.n1250 0.6755
R2665 VSS.n1250 VSS.n1249 0.6755
R2666 VSS.n1249 VSS.n236 0.6755
R2667 VSS.n286 VSS.n285 0.6755
R2668 VSS.n281 VSS.n278 0.6755
R2669 VSS.n278 VSS.n277 0.6755
R2670 VSS.n277 VSS.n274 0.6755
R2671 VSS.n271 VSS.n268 0.6755
R2672 VSS.n268 VSS.n267 0.6755
R2673 VSS.n1346 VSS.n1345 0.6755
R2674 VSS.n1345 VSS.n180 0.6755
R2675 VSS.n288 VSS.n180 0.6755
R2676 VSS.n289 VSS.n288 0.6755
R2677 VSS.n290 VSS.n289 0.6755
R2678 VSS.n291 VSS.n290 0.6755
R2679 VSS.n292 VSS.n291 0.6755
R2680 VSS.n292 VSS.n287 0.6755
R2681 VSS.n1289 VSS.n1288 0.6755
R2682 VSS.n1289 VSS.n200 0.6755
R2683 VSS.n1294 VSS.n200 0.6755
R2684 VSS.n1295 VSS.n1294 0.6755
R2685 VSS.n1298 VSS.n198 0.6755
R2686 VSS.n1303 VSS.n198 0.6755
R2687 VSS.n1305 VSS.n1304 0.6755
R2688 VSS.n1306 VSS.n1305 0.6755
R2689 VSS.n1307 VSS.n1306 0.6755
R2690 VSS.n1307 VSS.n197 0.6755
R2691 VSS.n1243 VSS.n197 0.6755
R2692 VSS.n1244 VSS.n1243 0.6755
R2693 VSS.n1245 VSS.n1244 0.6755
R2694 VSS.n1245 VSS.n1242 0.6755
R2695 VSS.n1223 VSS.n1221 0.6755
R2696 VSS.n1229 VSS.n1226 0.6755
R2697 VSS.n1230 VSS.n1229 0.6755
R2698 VSS.n1233 VSS.n1230 0.6755
R2699 VSS.n1239 VSS.n1236 0.6755
R2700 VSS.n1241 VSS.n1239 0.6755
R2701 VSS.n1213 VSS.n203 0.6755
R2702 VSS.n1214 VSS.n1213 0.6755
R2703 VSS.n1215 VSS.n1214 0.6755
R2704 VSS.n1216 VSS.n1215 0.6755
R2705 VSS.n1217 VSS.n1216 0.6755
R2706 VSS.n1218 VSS.n1217 0.6755
R2707 VSS.n1219 VSS.n1218 0.6755
R2708 VSS.n1220 VSS.n1219 0.6755
R2709 VSS.n1144 VSS.n1142 0.653
R2710 VSS.n1174 VSS.n342 0.653
R2711 VSS.n1433 VSS.n48 0.653
R2712 VSS.n760 VSS.n759 0.653
R2713 VSS.n840 VSS.n837 0.653
R2714 VSS.n872 VSS.n871 0.653
R2715 VSS.n1079 VSS.n1078 0.653
R2716 VSS.n1064 VSS.n387 0.61925
R2717 VSS.n253 VSS.n251 0.563
R2718 VSS.n1401 VSS.n1400 0.563
R2719 VSS.n283 VSS.n281 0.563
R2720 VSS.n1226 VSS.n1225 0.563
R2721 VSS.n1121 VSS.n354 0.5405
R2722 VSS.n1104 VSS.n355 0.5405
R2723 VSS.n1024 VSS.n392 0.5405
R2724 VSS.n1032 VSS.n1031 0.5405
R2725 VSS.n613 VSS.n612 0.5405
R2726 VSS.n621 VSS.n620 0.5405
R2727 VSS.n677 VSS.n676 0.5405
R2728 VSS.n647 VSS.n646 0.5405
R2729 VSS.n918 VSS.n537 0.5405
R2730 VSS.n566 VSS.n565 0.5405
R2731 VSS.n213 VSS.n209 0.5405
R2732 VSS.n221 VSS.n220 0.5405
R2733 VSS.n1263 VSS.n205 0.5405
R2734 VSS.n1271 VSS.n1270 0.5405
R2735 VSS.n257 VSS.n256 0.5405
R2736 VSS.n1396 VSS.n1395 0.5405
R2737 VSS.n287 VSS.n286 0.5405
R2738 VSS.n1221 VSS.n1220 0.5405
R2739 VSS.n1064 VSS.n1063 0.50675
R2740 VSS.n586 VSS.n585 0.50675
R2741 VSS.n434 VSS.n429 0.50675
R2742 VSS.n457 VSS.n439 0.50675
R2743 VSS.n971 VSS.n970 0.50675
R2744 VSS.n1438 VSS.n1437 0.48425
R2745 VSS.n728 VSS.n709 0.48425
R2746 VSS.n1437 VSS.n3 0.4505
R2747 VSS.n1433 VSS.n1432 0.4505
R2748 VSS.n761 VSS.n760 0.4505
R2749 VSS.n765 VSS.n709 0.4505
R2750 VSS.n1036 VSS.n392 0.4505
R2751 VSS.n1037 VSS.n1036 0.4505
R2752 VSS.n1037 VSS.n390 0.4505
R2753 VSS.n612 VSS.n390 0.4505
R2754 VSS.n1033 VSS.n1032 0.4505
R2755 VSS.n1033 VSS.n397 0.4505
R2756 VSS.n622 VSS.n397 0.4505
R2757 VSS.n622 VSS.n621 0.4505
R2758 VSS.n1272 VSS.n1271 0.4505
R2759 VSS.n1272 VSS.n1260 0.4505
R2760 VSS.n1260 VSS.n1259 0.4505
R2761 VSS.n1259 VSS.n209 0.4505
R2762 VSS.n1275 VSS.n205 0.4505
R2763 VSS.n1276 VSS.n1275 0.4505
R2764 VSS.n1276 VSS.n204 0.4505
R2765 VSS.n221 VSS.n204 0.4505
R2766 VSS.n1351 VSS.n150 0.4505
R2767 VSS.n177 VSS.n155 0.4505
R2768 VSS.n1323 VSS.n179 0.4505
R2769 VSS.n1287 VSS.n1283 0.4505
R2770 VSS.n1039 VSS.n1038 0.4405
R2771 VSS.n1278 VSS.n1277 0.4405
R2772 VSS.n1076 VSS.n1075 0.430889
R2773 VSS.n1076 VSS.n382 0.430889
R2774 VSS.n1076 VSS.n381 0.430889
R2775 VSS.n1076 VSS.n380 0.430889
R2776 VSS.n1124 VSS.n349 0.430889
R2777 VSS.n1124 VSS.n348 0.430889
R2778 VSS.n1124 VSS.n347 0.430889
R2779 VSS.n1124 VSS.n1123 0.430889
R2780 VSS.n443 VSS.n424 0.430889
R2781 VSS.n451 VSS.n424 0.430889
R2782 VSS.n453 VSS.n424 0.430889
R2783 VSS.n459 VSS.n424 0.430889
R2784 VSS.n936 VSS.n531 0.430889
R2785 VSS.n936 VSS.n532 0.430889
R2786 VSS.n936 VSS.n533 0.430889
R2787 VSS.n936 VSS.n935 0.430889
R2788 VSS.n159 VSS.n140 0.430889
R2789 VSS.n167 VSS.n140 0.430889
R2790 VSS.n169 VSS.n140 0.430889
R2791 VSS.n175 VSS.n140 0.430889
R2792 VSS.n1417 VSS.n60 0.430889
R2793 VSS.n1417 VSS.n59 0.430889
R2794 VSS.n1417 VSS.n78 0.430889
R2795 VSS.n1417 VSS.n1416 0.430889
R2796 VSS.n1009 VSS.n424 0.430889
R2797 VSS.n1006 VSS.n424 0.430889
R2798 VSS.n430 VSS.n424 0.430889
R2799 VSS.n999 VSS.n424 0.430889
R2800 VSS.n936 VSS.n518 0.430889
R2801 VSS.n936 VSS.n517 0.430889
R2802 VSS.n936 VSS.n516 0.430889
R2803 VSS.n937 VSS.n936 0.430889
R2804 VSS.n1363 VSS.n140 0.430889
R2805 VSS.n1360 VSS.n140 0.430889
R2806 VSS.n146 VSS.n140 0.430889
R2807 VSS.n1353 VSS.n140 0.430889
R2808 VSS.n1417 VSS.n64 0.430889
R2809 VSS.n1417 VSS.n63 0.430889
R2810 VSS.n1417 VSS.n62 0.430889
R2811 VSS.n1417 VSS.n61 0.430889
R2812 VSS.n983 VSS.n424 0.430889
R2813 VSS.n477 VSS.n424 0.430889
R2814 VSS.n974 VSS.n424 0.430889
R2815 VSS.n964 VSS.n424 0.430889
R2816 VSS.n936 VSS.n527 0.430889
R2817 VSS.n936 VSS.n528 0.430889
R2818 VSS.n936 VSS.n529 0.430889
R2819 VSS.n936 VSS.n530 0.430889
R2820 VSS.n1336 VSS.n140 0.430889
R2821 VSS.n1316 VSS.n140 0.430889
R2822 VSS.n1327 VSS.n140 0.430889
R2823 VSS.n1318 VSS.n140 0.430889
R2824 VSS.n1417 VSS.n73 0.430889
R2825 VSS.n1417 VSS.n74 0.430889
R2826 VSS.n1417 VSS.n75 0.430889
R2827 VSS.n1417 VSS.n76 0.430889
R2828 VSS.n598 VSS.n424 0.430889
R2829 VSS.n577 VSS.n424 0.430889
R2830 VSS.n589 VSS.n424 0.430889
R2831 VSS.n579 VSS.n424 0.430889
R2832 VSS.n936 VSS.n523 0.430889
R2833 VSS.n936 VSS.n522 0.430889
R2834 VSS.n936 VSS.n521 0.430889
R2835 VSS.n936 VSS.n520 0.430889
R2836 VSS.n1300 VSS.n140 0.430889
R2837 VSS.n201 VSS.n140 0.430889
R2838 VSS.n1291 VSS.n140 0.430889
R2839 VSS.n1281 VSS.n140 0.430889
R2840 VSS.n1417 VSS.n69 0.430889
R2841 VSS.n1417 VSS.n68 0.430889
R2842 VSS.n1417 VSS.n67 0.430889
R2843 VSS.n1417 VSS.n66 0.430889
R2844 VSS.n252 VSS.t203 0.41
R2845 VSS.n252 VSS.t199 0.41
R2846 VSS.n1399 VSS.t200 0.41
R2847 VSS.n1399 VSS.t201 0.41
R2848 VSS.n282 VSS.t202 0.41
R2849 VSS.n282 VSS.t196 0.41
R2850 VSS.n1224 VSS.t198 0.41
R2851 VSS.n1224 VSS.t204 0.41
R2852 VSS.n596 VSS.n595 0.383
R2853 VSS.n663 VSS.n662 0.383
R2854 VSS.n425 VSS.n423 0.383
R2855 VSS.n633 VSS.n632 0.383
R2856 VSS.n447 VSS.n446 0.383
R2857 VSS.n931 VSS.n930 0.383
R2858 VSS.n981 VSS.n980 0.383
R2859 VSS.n552 VSS.n551 0.383
R2860 VSS.n1056 VSS.n1043 0.37175
R2861 VSS.n681 VSS.n389 0.37175
R2862 VSS.n996 VSS.n435 0.37175
R2863 VSS.n994 VSS.n993 0.37175
R2864 VSS.n963 VSS.n962 0.37175
R2865 VSS.n1350 VSS.n151 0.37175
R2866 VSS.n223 VSS.n178 0.37175
R2867 VSS.n1347 VSS.n1346 0.37175
R2868 VSS.n1280 VSS.n203 0.37175
R2869 VSS.n1110 VSS.n1106 0.338
R2870 VSS.n1111 VSS.n1110 0.338
R2871 VSS.n1024 VSS.n1023 0.338
R2872 VSS.n1023 VSS.n398 0.338
R2873 VSS.n1031 VSS.n398 0.338
R2874 VSS.n613 VSS.n609 0.338
R2875 VSS.n609 VSS.n608 0.338
R2876 VSS.n620 VSS.n608 0.338
R2877 VSS.n220 VSS.n219 0.338
R2878 VSS.n219 VSS.n212 0.338
R2879 VSS.n213 VSS.n212 0.338
R2880 VSS.n1263 VSS.n1262 0.338
R2881 VSS.n1262 VSS.n1261 0.338
R2882 VSS.n1270 VSS.n1261 0.338
R2883 VSS.n141 VSS.n139 0.338
R2884 VSS.n242 VSS.n241 0.338
R2885 VSS.n163 VSS.n162 0.338
R2886 VSS.n1412 VSS.n1410 0.338
R2887 VSS.n1334 VSS.n1333 0.338
R2888 VSS.n272 VSS.n271 0.338
R2889 VSS.n1298 VSS.n1297 0.338
R2890 VSS.n1236 VSS.n1235 0.338
R2891 VSS.n20 VSS.n6 0.337318
R2892 VSS.n19 VSS.n6 0.337318
R2893 VSS.n27 VSS.n6 0.337318
R2894 VSS.n16 VSS.n6 0.337318
R2895 VSS.n34 VSS.n6 0.337318
R2896 VSS.n37 VSS.n6 0.337318
R2897 VSS.n43 VSS.n6 0.337318
R2898 VSS.n45 VSS.n6 0.337318
R2899 VSS.n1176 VSS.n1132 0.337318
R2900 VSS.n1176 VSS.n1131 0.337318
R2901 VSS.n1176 VSS.n1130 0.337318
R2902 VSS.n1176 VSS.n1129 0.337318
R2903 VSS.n1176 VSS.n1128 0.337318
R2904 VSS.n1176 VSS.n1127 0.337318
R2905 VSS.n1176 VSS.n1126 0.337318
R2906 VSS.n1176 VSS.n1125 0.337318
R2907 VSS.n869 VSS.n868 0.337318
R2908 VSS.n869 VSS.n832 0.337318
R2909 VSS.n869 VSS.n831 0.337318
R2910 VSS.n869 VSS.n830 0.337318
R2911 VSS.n869 VSS.n829 0.337318
R2912 VSS.n869 VSS.n828 0.337318
R2913 VSS.n869 VSS.n827 0.337318
R2914 VSS.n869 VSS.n826 0.337318
R2915 VSS.n729 VSS.n379 0.337318
R2916 VSS.n735 VSS.n379 0.337318
R2917 VSS.n726 VSS.n379 0.337318
R2918 VSS.n743 VSS.n379 0.337318
R2919 VSS.n749 VSS.n379 0.337318
R2920 VSS.n721 VSS.n379 0.337318
R2921 VSS.n757 VSS.n379 0.337318
R2922 VSS.n1061 VSS.t224 0.3281
R2923 VSS.n1061 VSS.t227 0.3281
R2924 VSS.n1060 VSS.t225 0.3281
R2925 VSS.n1060 VSS.t226 0.3281
R2926 VSS.n385 VSS.t186 0.3281
R2927 VSS.n385 VSS.t188 0.3281
R2928 VSS.n384 VSS.t182 0.3281
R2929 VSS.n384 VSS.t184 0.3281
R2930 VSS.n1059 VSS.n1043 0.28175
R2931 VSS.n673 VSS.t110 0.2735
R2932 VSS.n673 VSS.t118 0.2735
R2933 VSS.n643 VSS.t111 0.2735
R2934 VSS.n643 VSS.t116 0.2735
R2935 VSS.n536 VSS.t112 0.2735
R2936 VSS.n536 VSS.t114 0.2735
R2937 VSS.n562 VSS.t115 0.2735
R2938 VSS.n562 VSS.t117 0.2735
R2939 VSS.n150 VSS.n145 0.2255
R2940 VSS.n142 VSS.n141 0.2255
R2941 VSS.n243 VSS.n242 0.2255
R2942 VSS.n173 VSS.n155 0.2255
R2943 VSS.n164 VSS.n163 0.2255
R2944 VSS.n1410 VSS.n1409 0.2255
R2945 VSS.n1324 VSS.n1323 0.2255
R2946 VSS.n1333 VSS.n1332 0.2255
R2947 VSS.n273 VSS.n272 0.2255
R2948 VSS.n1288 VSS.n1287 0.2255
R2949 VSS.n1297 VSS.n1296 0.2255
R2950 VSS.n1235 VSS.n1234 0.2255
R2951 VSS.n1438 VSS.n2 0.16925
R2952 VSS.n731 VSS.n728 0.16925
R2953 VSS.n1063 VSS.n1059 0.16925
R2954 VSS.n581 VSS.n389 0.16925
R2955 VSS.n585 VSS.n581 0.16925
R2956 VSS.n997 VSS.n996 0.16925
R2957 VSS.n997 VSS.n434 0.16925
R2958 VSS.n994 VSS.n461 0.16925
R2959 VSS.n461 VSS.n439 0.16925
R2960 VSS.n966 VSS.n963 0.16925
R2961 VSS.n970 VSS.n966 0.16925
R2962 VSS.n1351 VSS.n1350 0.16925
R2963 VSS.n178 VSS.n177 0.16925
R2964 VSS.n1347 VSS.n179 0.16925
R2965 VSS.n1283 VSS.n1280 0.16925
R2966 VSS.n1108 VSS.t73 0.1643
R2967 VSS.n1108 VSS.t67 0.1643
R2968 VSS.n1107 VSS.t69 0.1643
R2969 VSS.n1107 VSS.t71 0.1643
R2970 VSS.n148 VSS.t94 0.1643
R2971 VSS.n148 VSS.t96 0.1643
R2972 VSS.n147 VSS.t91 0.1643
R2973 VSS.n147 VSS.t95 0.1643
R2974 VSS.n153 VSS.t90 0.1643
R2975 VSS.n153 VSS.t93 0.1643
R2976 VSS.n152 VSS.t85 0.1643
R2977 VSS.n152 VSS.t88 0.1643
R2978 VSS.n1321 VSS.t99 0.1643
R2979 VSS.n1321 VSS.t100 0.1643
R2980 VSS.n1320 VSS.t86 0.1643
R2981 VSS.n1320 VSS.t98 0.1643
R2982 VSS.n1285 VSS.t102 0.1643
R2983 VSS.n1285 VSS.t103 0.1643
R2984 VSS.n1284 VSS.t97 0.1643
R2985 VSS.n1284 VSS.t101 0.1643
R2986 VSS.n594 VSS.n593 0.158
R2987 VSS.n665 VSS.n664 0.158
R2988 VSS.n427 VSS.n426 0.158
R2989 VSS.n635 VSS.n634 0.158
R2990 VSS.n449 VSS.n448 0.158
R2991 VSS.n929 VSS.n928 0.158
R2992 VSS.n979 VSS.n978 0.158
R2993 VSS.n554 VSS.n553 0.158
R2994 VSS.n595 VSS.n594 0.1355
R2995 VSS.n664 VSS.n663 0.1355
R2996 VSS.n426 VSS.n425 0.1355
R2997 VSS.n634 VSS.n633 0.1355
R2998 VSS.n448 VSS.n447 0.1355
R2999 VSS.n930 VSS.n929 0.1355
R3000 VSS.n980 VSS.n979 0.1355
R3001 VSS.n553 VSS.n552 0.1355
R3002 VSS.n485 VSS.t160 0.113367
R3003 VSS.t92 VSS.n196 0.113367
R3004 VSS.n143 VSS.n142 0.113
R3005 VSS.n255 VSS.n253 0.113
R3006 VSS.n244 VSS.n243 0.113
R3007 VSS.n165 VSS.n164 0.113
R3008 VSS.n1400 VSS.n1398 0.113
R3009 VSS.n1409 VSS.n1408 0.113
R3010 VSS.n1332 VSS.n1331 0.113
R3011 VSS.n285 VSS.n283 0.113
R3012 VSS.n274 VSS.n273 0.113
R3013 VSS.n1296 VSS.n1295 0.113
R3014 VSS.n1225 VSS.n1223 0.113
R3015 VSS.n1234 VSS.n1233 0.113
R3016 VSS.n583 VSS.t176 0.1097
R3017 VSS.n583 VSS.t177 0.1097
R3018 VSS.n582 VSS.t162 0.1097
R3019 VSS.n582 VSS.t175 0.1097
R3020 VSS.n432 VSS.t170 0.1097
R3021 VSS.n432 VSS.t171 0.1097
R3022 VSS.n431 VSS.t159 0.1097
R3023 VSS.n431 VSS.t169 0.1097
R3024 VSS.n437 VSS.t167 0.1097
R3025 VSS.n437 VSS.t161 0.1097
R3026 VSS.n436 VSS.t163 0.1097
R3027 VSS.n436 VSS.t165 0.1097
R3028 VSS.n968 VSS.t173 0.1097
R3029 VSS.n968 VSS.t174 0.1097
R3030 VSS.n967 VSS.t172 0.1097
R3031 VSS.n967 VSS.t168 0.1097
R3032 VSS.n1041 VSS.n388 0.0597105
R3033 VSS.n1348 VSS.n1 0.0597105
R3034 VSS.n1067 VSS.n387 0.05675
R3035 a_43000_n37702.n1 a_43000_n37702.t2 19.0047
R3036 a_43000_n37702.n1 a_43000_n37702.n0 8.64669
R3037 a_43000_n37702.n2 a_43000_n37702.n1 6.75196
R3038 a_43000_n37702.n2 a_43000_n37702.t0 5.9772
R3039 a_43000_n37702.n0 a_43000_n37702.t3 5.9772
R3040 a_43000_n37702.n0 a_43000_n37702.t4 5.9772
R3041 a_43000_n37702.t1 a_43000_n37702.n2 5.9772
R3042 a_40000_n37702.n1 a_40000_n37702.t2 19.0047
R3043 a_40000_n37702.n1 a_40000_n37702.n0 8.64669
R3044 a_40000_n37702.n2 a_40000_n37702.n1 6.75196
R3045 a_40000_n37702.n2 a_40000_n37702.t0 5.9772
R3046 a_40000_n37702.n0 a_40000_n37702.t3 5.9772
R3047 a_40000_n37702.n0 a_40000_n37702.t4 5.9772
R3048 a_40000_n37702.t1 a_40000_n37702.n2 5.9772
R3049 a_37000_n37702.n1 a_37000_n37702.t2 19.0047
R3050 a_37000_n37702.n1 a_37000_n37702.n0 8.64669
R3051 a_37000_n37702.n2 a_37000_n37702.n1 6.75196
R3052 a_37000_n37702.n2 a_37000_n37702.t0 5.9772
R3053 a_37000_n37702.n0 a_37000_n37702.t3 5.9772
R3054 a_37000_n37702.n0 a_37000_n37702.t4 5.9772
R3055 a_37000_n37702.t1 a_37000_n37702.n2 5.9772
R3056 a_34000_n37702.n1 a_34000_n37702.t2 19.0047
R3057 a_34000_n37702.n2 a_34000_n37702.n1 8.64669
R3058 a_34000_n37702.n1 a_34000_n37702.n0 6.75196
R3059 a_34000_n37702.n2 a_34000_n37702.t0 5.9772
R3060 a_34000_n37702.n0 a_34000_n37702.t3 5.9772
R3061 a_34000_n37702.n0 a_34000_n37702.t4 5.9772
R3062 a_34000_n37702.t1 a_34000_n37702.n2 5.9772
R3063 a_31000_n37702.n1 a_31000_n37702.t0 19.0047
R3064 a_31000_n37702.n2 a_31000_n37702.n1 8.64669
R3065 a_31000_n37702.n1 a_31000_n37702.n0 6.75196
R3066 a_31000_n37702.n2 a_31000_n37702.t1 5.9772
R3067 a_31000_n37702.n0 a_31000_n37702.t3 5.9772
R3068 a_31000_n37702.n0 a_31000_n37702.t4 5.9772
R3069 a_31000_n37702.t2 a_31000_n37702.n2 5.9772
R3070 a_24600_n37702.n1 a_24600_n37702.t4 19.0047
R3071 a_24600_n37702.n2 a_24600_n37702.n1 8.64669
R3072 a_24600_n37702.n1 a_24600_n37702.n0 6.75196
R3073 a_24600_n37702.n2 a_24600_n37702.t0 5.9772
R3074 a_24600_n37702.n0 a_24600_n37702.t2 5.9772
R3075 a_24600_n37702.n0 a_24600_n37702.t3 5.9772
R3076 a_24600_n37702.t1 a_24600_n37702.n2 5.9772
R3077 a_21600_n37702.n1 a_21600_n37702.t4 19.0047
R3078 a_21600_n37702.n2 a_21600_n37702.n1 8.64669
R3079 a_21600_n37702.n1 a_21600_n37702.n0 6.75196
R3080 a_21600_n37702.n2 a_21600_n37702.t0 5.9772
R3081 a_21600_n37702.n0 a_21600_n37702.t2 5.9772
R3082 a_21600_n37702.n0 a_21600_n37702.t3 5.9772
R3083 a_21600_n37702.t1 a_21600_n37702.n2 5.9772
R3084 a_18600_n37702.n1 a_18600_n37702.t2 19.0047
R3085 a_18600_n37702.n2 a_18600_n37702.n1 8.64669
R3086 a_18600_n37702.n1 a_18600_n37702.n0 6.75196
R3087 a_18600_n37702.n2 a_18600_n37702.t0 5.9772
R3088 a_18600_n37702.n0 a_18600_n37702.t3 5.9772
R3089 a_18600_n37702.n0 a_18600_n37702.t4 5.9772
R3090 a_18600_n37702.t1 a_18600_n37702.n2 5.9772
R3091 a_15600_n37702.n1 a_15600_n37702.t2 19.0047
R3092 a_15600_n37702.n1 a_15600_n37702.n0 8.64669
R3093 a_15600_n37702.n2 a_15600_n37702.n1 6.75196
R3094 a_15600_n37702.n2 a_15600_n37702.t0 5.9772
R3095 a_15600_n37702.n0 a_15600_n37702.t3 5.9772
R3096 a_15600_n37702.n0 a_15600_n37702.t4 5.9772
R3097 a_15600_n37702.t1 a_15600_n37702.n2 5.9772
R3098 a_12600_n37702.n1 a_12600_n37702.t4 19.0047
R3099 a_12600_n37702.n2 a_12600_n37702.n1 8.64669
R3100 a_12600_n37702.n1 a_12600_n37702.n0 6.75196
R3101 a_12600_n37702.n2 a_12600_n37702.t0 5.9772
R3102 a_12600_n37702.n0 a_12600_n37702.t2 5.9772
R3103 a_12600_n37702.n0 a_12600_n37702.t3 5.9772
R3104 a_12600_n37702.t1 a_12600_n37702.n2 5.9772
R3105 a_n13000_n37702.n1 a_n13000_n37702.t0 19.0047
R3106 a_n13000_n37702.n1 a_n13000_n37702.n0 8.64669
R3107 a_n13000_n37702.n2 a_n13000_n37702.n1 6.75196
R3108 a_n13000_n37702.n2 a_n13000_n37702.t1 5.9772
R3109 a_n13000_n37702.n0 a_n13000_n37702.t3 5.9772
R3110 a_n13000_n37702.n0 a_n13000_n37702.t4 5.9772
R3111 a_n13000_n37702.t2 a_n13000_n37702.n2 5.9772
R3112 a_n16000_n37702.n1 a_n16000_n37702.t0 19.0047
R3113 a_n16000_n37702.n1 a_n16000_n37702.n0 8.64669
R3114 a_n16000_n37702.n2 a_n16000_n37702.n1 6.75196
R3115 a_n16000_n37702.n2 a_n16000_n37702.t1 5.9772
R3116 a_n16000_n37702.n0 a_n16000_n37702.t3 5.9772
R3117 a_n16000_n37702.n0 a_n16000_n37702.t4 5.9772
R3118 a_n16000_n37702.t2 a_n16000_n37702.n2 5.9772
R3119 a_n19000_n37702.n1 a_n19000_n37702.t4 19.0047
R3120 a_n19000_n37702.n2 a_n19000_n37702.n1 8.64669
R3121 a_n19000_n37702.n1 a_n19000_n37702.n0 6.75196
R3122 a_n19000_n37702.n2 a_n19000_n37702.t0 5.9772
R3123 a_n19000_n37702.n0 a_n19000_n37702.t2 5.9772
R3124 a_n19000_n37702.n0 a_n19000_n37702.t3 5.9772
R3125 a_n19000_n37702.t1 a_n19000_n37702.n2 5.9772
R3126 a_n22000_n37702.n1 a_n22000_n37702.t4 19.0047
R3127 a_n22000_n37702.n1 a_n22000_n37702.n0 8.64669
R3128 a_n22000_n37702.n2 a_n22000_n37702.n1 6.75196
R3129 a_n22000_n37702.n2 a_n22000_n37702.t0 5.9772
R3130 a_n22000_n37702.n0 a_n22000_n37702.t2 5.9772
R3131 a_n22000_n37702.n0 a_n22000_n37702.t3 5.9772
R3132 a_n22000_n37702.t1 a_n22000_n37702.n2 5.9772
R3133 a_n25000_n37702.n1 a_n25000_n37702.t0 19.0047
R3134 a_n25000_n37702.n1 a_n25000_n37702.n0 8.64669
R3135 a_n25000_n37702.n2 a_n25000_n37702.n1 6.75196
R3136 a_n25000_n37702.n2 a_n25000_n37702.t1 5.9772
R3137 a_n25000_n37702.n0 a_n25000_n37702.t3 5.9772
R3138 a_n25000_n37702.n0 a_n25000_n37702.t4 5.9772
R3139 a_n25000_n37702.t2 a_n25000_n37702.n2 5.9772
R3140 a_n31400_n37702.n1 a_n31400_n37702.t0 19.0047
R3141 a_n31400_n37702.n2 a_n31400_n37702.n1 8.64669
R3142 a_n31400_n37702.n1 a_n31400_n37702.n0 6.75196
R3143 a_n31400_n37702.n2 a_n31400_n37702.t1 5.9772
R3144 a_n31400_n37702.n0 a_n31400_n37702.t3 5.9772
R3145 a_n31400_n37702.n0 a_n31400_n37702.t4 5.9772
R3146 a_n31400_n37702.t2 a_n31400_n37702.n2 5.9772
R3147 a_n34400_n37702.n1 a_n34400_n37702.t0 19.0047
R3148 a_n34400_n37702.n1 a_n34400_n37702.n0 8.64669
R3149 a_n34400_n37702.n2 a_n34400_n37702.n1 6.75196
R3150 a_n34400_n37702.n2 a_n34400_n37702.t1 5.9772
R3151 a_n34400_n37702.n0 a_n34400_n37702.t3 5.9772
R3152 a_n34400_n37702.n0 a_n34400_n37702.t4 5.9772
R3153 a_n34400_n37702.t2 a_n34400_n37702.n2 5.9772
R3154 a_n37400_n37702.n1 a_n37400_n37702.t0 19.0047
R3155 a_n37400_n37702.n1 a_n37400_n37702.n0 8.64669
R3156 a_n37400_n37702.n2 a_n37400_n37702.n1 6.75196
R3157 a_n37400_n37702.n2 a_n37400_n37702.t1 5.9772
R3158 a_n37400_n37702.n0 a_n37400_n37702.t3 5.9772
R3159 a_n37400_n37702.n0 a_n37400_n37702.t4 5.9772
R3160 a_n37400_n37702.t2 a_n37400_n37702.n2 5.9772
R3161 a_n40400_n37702.n1 a_n40400_n37702.t2 19.0047
R3162 a_n40400_n37702.n2 a_n40400_n37702.n1 8.64669
R3163 a_n40400_n37702.n1 a_n40400_n37702.n0 6.75196
R3164 a_n40400_n37702.n2 a_n40400_n37702.t0 5.9772
R3165 a_n40400_n37702.n0 a_n40400_n37702.t3 5.9772
R3166 a_n40400_n37702.n0 a_n40400_n37702.t4 5.9772
R3167 a_n40400_n37702.t1 a_n40400_n37702.n2 5.9772
R3168 a_n43400_n37702.n1 a_n43400_n37702.t2 19.0047
R3169 a_n43400_n37702.n2 a_n43400_n37702.n1 8.64669
R3170 a_n43400_n37702.n1 a_n43400_n37702.n0 6.75196
R3171 a_n43400_n37702.n2 a_n43400_n37702.t0 5.9772
R3172 a_n43400_n37702.n0 a_n43400_n37702.t3 5.9772
R3173 a_n43400_n37702.n0 a_n43400_n37702.t4 5.9772
R3174 a_n43400_n37702.t1 a_n43400_n37702.n2 5.9772
R3175 a_27028_n400.n0 a_27028_n400.t0 16.0424
R3176 a_27028_n400.n0 a_27028_n400.t3 14.8582
R3177 a_27028_n400.n1 a_27028_n400.n0 6.02323
R3178 a_27028_n400.n1 a_27028_n400.t1 5.95154
R3179 a_27028_n400.t2 a_27028_n400.n1 5.95154
R3180 a_24948_n500.n6 a_24948_n500.n4 19.8938
R3181 a_24948_n500.n6 a_24948_n500.n5 19.1827
R3182 a_24948_n500.t6 a_24948_n500.n13 5.60716
R3183 a_24948_n500.n2 a_24948_n500.t3 5.60716
R3184 a_24948_n500.n12 a_24948_n500.n1 5.44336
R3185 a_24948_n500.n7 a_24948_n500.n0 4.59466
R3186 a_24948_n500.n9 a_24948_n500.n8 4.58471
R3187 a_24948_n500.n10 a_24948_n500.n2 4.5005
R3188 a_24948_n500.n12 a_24948_n500.n11 4.5005
R3189 a_24948_n500.n13 a_24948_n500.n0 4.5005
R3190 a_24948_n500.n10 a_24948_n500.n9 4.5005
R3191 a_24948_n500.n11 a_24948_n500.n3 4.5005
R3192 a_24948_n500.n8 a_24948_n500.n7 2.22546
R3193 a_24948_n500.n8 a_24948_n500.n6 0.351553
R3194 a_24948_n500.n4 a_24948_n500.t7 0.3281
R3195 a_24948_n500.n4 a_24948_n500.t0 0.3281
R3196 a_24948_n500.n5 a_24948_n500.t2 0.3281
R3197 a_24948_n500.n5 a_24948_n500.t1 0.3281
R3198 a_24948_n500.n12 a_24948_n500.n2 0.189974
R3199 a_24948_n500.n13 a_24948_n500.n12 0.189974
R3200 a_24948_n500.n11 a_24948_n500.n10 0.189974
R3201 a_24948_n500.n11 a_24948_n500.n0 0.189974
R3202 a_24948_n500.n9 a_24948_n500.n3 0.189974
R3203 a_24948_n500.n1 a_24948_n500.t4 0.1643
R3204 a_24948_n500.n1 a_24948_n500.t5 0.1643
R3205 a_24948_n500.n7 a_24948_n500.n3 0.092941
R3206 a_n28972_n400.n0 a_n28972_n400.t3 16.0424
R3207 a_n28972_n400.n0 a_n28972_n400.t0 14.8582
R3208 a_n28972_n400.n1 a_n28972_n400.n0 5.90481
R3209 a_n28972_n400.n1 a_n28972_n400.t1 5.67287
R3210 a_n28972_n400.t2 a_n28972_n400.n1 5.67287
R3211 a_n31052_n500.n5 a_n31052_n500.n3 19.8938
R3212 a_n31052_n500.n5 a_n31052_n500.n4 19.1827
R3213 a_n31052_n500.n0 a_n31052_n500.t7 5.85122
R3214 a_n31052_n500.n11 a_n31052_n500.t4 5.85122
R3215 a_n31052_n500.n13 a_n31052_n500.n12 5.74202
R3216 a_n31052_n500.n7 a_n31052_n500.n6 4.59466
R3217 a_n31052_n500.n9 a_n31052_n500.n8 4.58471
R3218 a_n31052_n500.n11 a_n31052_n500.n10 4.5005
R3219 a_n31052_n500.n12 a_n31052_n500.n1 4.5005
R3220 a_n31052_n500.n6 a_n31052_n500.n0 4.5005
R3221 a_n31052_n500.n10 a_n31052_n500.n9 4.5005
R3222 a_n31052_n500.n2 a_n31052_n500.n1 4.5005
R3223 a_n31052_n500.n8 a_n31052_n500.n7 2.22546
R3224 a_n31052_n500.n3 a_n31052_n500.t0 0.3281
R3225 a_n31052_n500.n3 a_n31052_n500.t1 0.3281
R3226 a_n31052_n500.n4 a_n31052_n500.t3 0.3281
R3227 a_n31052_n500.n4 a_n31052_n500.t2 0.3281
R3228 a_n31052_n500.n8 a_n31052_n500.n5 0.219974
R3229 a_n31052_n500.n12 a_n31052_n500.n11 0.189974
R3230 a_n31052_n500.n12 a_n31052_n500.n0 0.189974
R3231 a_n31052_n500.n10 a_n31052_n500.n1 0.189974
R3232 a_n31052_n500.n6 a_n31052_n500.n1 0.189974
R3233 a_n31052_n500.n9 a_n31052_n500.n2 0.189974
R3234 a_n31052_n500.n13 a_n31052_n500.t5 0.1097
R3235 a_n31052_n500.t6 a_n31052_n500.n13 0.1097
R3236 a_n31052_n500.n7 a_n31052_n500.n2 0.092941
R3237 a_27028_12400.n0 a_27028_12400.t0 16.0424
R3238 a_27028_12400.n0 a_27028_12400.t1 14.8582
R3239 a_27028_12400.n1 a_27028_12400.n0 6.02323
R3240 a_27028_12400.n1 a_27028_12400.t3 5.95154
R3241 a_27028_12400.t2 a_27028_12400.n1 5.95154
R3242 XGAIN.XSTART.NODEN.n6 XGAIN.XSTART.NODEN.t5 96.4943
R3243 XGAIN.XSTART.NODEN.n0 XGAIN.XSTART.NODEN.t7 74.5104
R3244 XGAIN.XSTART.NODEN.n0 XGAIN.XSTART.NODEN.t8 74.5104
R3245 XGAIN.XSTART.NODEN.n2 XGAIN.XSTART.NODEN.t6 35.6252
R3246 XGAIN.XSTART.NODEN.n6 XGAIN.XSTART.NODEN.t3 31.3566
R3247 XGAIN.XSTART.NODEN XGAIN.XSTART.NODEN.n0 26.0508
R3248 XGAIN.XSTART.NODEN XGAIN.XSTART.NODEN.t4 19.0295
R3249 XGAIN.XSTART.NODEN.n1 XGAIN.XSTART.NODEN 17.29
R3250 XGAIN.XSTART.NODEN.n1 XGAIN.XSTART.NODEN 15.2439
R3251 XGAIN.XSTART.NODEN.n6 XGAIN.XSTART.NODEN.t2 11.0041
R3252 XGAIN.XSTART.NODEN.n2 XGAIN.XSTART.NODEN.n1 6.15839
R3253 XGAIN.XSTART.NODEN.n3 XGAIN.XSTART.NODEN.t0 5.69917
R3254 XGAIN.XSTART.NODEN.n4 XGAIN.XSTART.NODEN.t1 5.69917
R3255 XGAIN.XSTART.NODEN.n3 XGAIN.XSTART.NODEN.n2 4.5805
R3256 XGAIN.XSTART.NODEN.n5 XGAIN.XSTART.NODEN.n4 4.5005
R3257 XGAIN.XSTART.NODEN.n4 XGAIN.XSTART.NODEN.n3 0.189974
R3258 XGAIN.XSTART.NODEN XGAIN.XSTART.NODEN.n5 0.1705
R3259 XGAIN.XSTART.NODEN XGAIN.XSTART.NODEN.n6 0.1505
R3260 XGAIN.XSTART.NODEN.n5 XGAIN.XSTART.NODEN.n2 0.0805
R3261 a_24948_12300.n6 a_24948_12300.n4 19.8938
R3262 a_24948_12300.n6 a_24948_12300.n5 19.1827
R3263 a_24948_12300.t6 a_24948_12300.n13 5.60716
R3264 a_24948_12300.n2 a_24948_12300.t3 5.60716
R3265 a_24948_12300.n12 a_24948_12300.n1 5.44336
R3266 a_24948_12300.n7 a_24948_12300.n0 4.59466
R3267 a_24948_12300.n9 a_24948_12300.n8 4.58471
R3268 a_24948_12300.n10 a_24948_12300.n2 4.5005
R3269 a_24948_12300.n12 a_24948_12300.n11 4.5005
R3270 a_24948_12300.n13 a_24948_12300.n0 4.5005
R3271 a_24948_12300.n10 a_24948_12300.n9 4.5005
R3272 a_24948_12300.n11 a_24948_12300.n3 4.5005
R3273 a_24948_12300.n8 a_24948_12300.n7 2.22546
R3274 a_24948_12300.n8 a_24948_12300.n6 0.351553
R3275 a_24948_12300.n4 a_24948_12300.t0 0.3281
R3276 a_24948_12300.n4 a_24948_12300.t1 0.3281
R3277 a_24948_12300.n5 a_24948_12300.t7 0.3281
R3278 a_24948_12300.n5 a_24948_12300.t2 0.3281
R3279 a_24948_12300.n12 a_24948_12300.n2 0.189974
R3280 a_24948_12300.n13 a_24948_12300.n12 0.189974
R3281 a_24948_12300.n11 a_24948_12300.n10 0.189974
R3282 a_24948_12300.n11 a_24948_12300.n0 0.189974
R3283 a_24948_12300.n9 a_24948_12300.n3 0.189974
R3284 a_24948_12300.n1 a_24948_12300.t4 0.1643
R3285 a_24948_12300.n1 a_24948_12300.t5 0.1643
R3286 a_24948_12300.n7 a_24948_12300.n3 0.092941
R3287 XGAIN.XSTART.NODEP.n3 XGAIN.XSTART.NODEP.t5 94.691
R3288 XGAIN.XSTART.NODEP.n0 XGAIN.XSTART.NODEP.t7 74.5104
R3289 XGAIN.XSTART.NODEP.n0 XGAIN.XSTART.NODEP.t8 74.5104
R3290 XGAIN.XSTART.NODEP.n2 XGAIN.XSTART.NODEP.t6 35.6252
R3291 XGAIN.XSTART.NODEP XGAIN.XSTART.NODEP.n0 26.0508
R3292 XGAIN.XSTART.NODEP.n3 XGAIN.XSTART.NODEP.t4 21.9418
R3293 XGAIN.XSTART.NODEP XGAIN.XSTART.NODEP.t0 19.1124
R3294 XGAIN.XSTART.NODEP.n1 XGAIN.XSTART.NODEP 17.29
R3295 XGAIN.XSTART.NODEP.n1 XGAIN.XSTART.NODEP 15.0663
R3296 XGAIN.XSTART.NODEP.n4 XGAIN.XSTART.NODEP.t3 10.9241
R3297 XGAIN.XSTART.NODEP.n2 XGAIN.XSTART.NODEP.n1 6.15839
R3298 XGAIN.XSTART.NODEP.n6 XGAIN.XSTART.NODEP.t1 5.69917
R3299 XGAIN.XSTART.NODEP.n7 XGAIN.XSTART.NODEP.t2 5.69917
R3300 XGAIN.XSTART.NODEP.n4 XGAIN.XSTART.NODEP.n3 4.80115
R3301 XGAIN.XSTART.NODEP.n8 XGAIN.XSTART.NODEP.n7 4.5005
R3302 XGAIN.XSTART.NODEP.n6 XGAIN.XSTART.NODEP.n5 4.5005
R3303 XGAIN.XSTART.NODEP.n5 XGAIN.XSTART.NODEP.n4 0.3205
R3304 XGAIN.XSTART.NODEP.n7 XGAIN.XSTART.NODEP.n6 0.189974
R3305 XGAIN.XSTART.NODEP.n8 XGAIN.XSTART.NODEP.n2 0.0805
R3306 XGAIN.XSTART.NODEP.n5 XGAIN.XSTART.NODEP.n2 0.0805
R3307 XGAIN.XSTART.NODEP XGAIN.XSTART.NODEP.n8 0.0405
R3308 a_n28972_12400.n0 a_n28972_12400.t0 16.0424
R3309 a_n28972_12400.n0 a_n28972_12400.t3 14.8582
R3310 a_n28972_12400.n1 a_n28972_12400.n0 5.90481
R3311 a_n28972_12400.n1 a_n28972_12400.t1 5.67287
R3312 a_n28972_12400.t2 a_n28972_12400.n1 5.67287
R3313 XFAST.XSTART.NODEN.n6 XFAST.XSTART.NODEN.t5 96.4943
R3314 XFAST.XSTART.NODEN.n0 XFAST.XSTART.NODEN.t7 74.5104
R3315 XFAST.XSTART.NODEN.n0 XFAST.XSTART.NODEN.t8 74.5104
R3316 XFAST.XSTART.NODEN.n2 XFAST.XSTART.NODEN.t6 31.5274
R3317 XFAST.XSTART.NODEN.n6 XFAST.XSTART.NODEN.t4 31.4224
R3318 XFAST.XSTART.NODEN XFAST.XSTART.NODEN.n0 26.0508
R3319 XFAST.XSTART.NODEN XFAST.XSTART.NODEN.t3 19.0295
R3320 XFAST.XSTART.NODEN.n1 XFAST.XSTART.NODEN 17.29
R3321 XFAST.XSTART.NODEN.n1 XFAST.XSTART.NODEN 15.2439
R3322 XFAST.XSTART.NODEN.n6 XFAST.XSTART.NODEN.t2 11.0041
R3323 XFAST.XSTART.NODEN.n2 XFAST.XSTART.NODEN.n1 6.15839
R3324 XFAST.XSTART.NODEN.n4 XFAST.XSTART.NODEN.t0 5.69917
R3325 XFAST.XSTART.NODEN.n3 XFAST.XSTART.NODEN.t1 5.69917
R3326 XFAST.XSTART.NODEN.n3 XFAST.XSTART.NODEN.n2 4.5805
R3327 XFAST.XSTART.NODEN.n5 XFAST.XSTART.NODEN.n4 4.5005
R3328 XFAST.XSTART.NODEN.n4 XFAST.XSTART.NODEN.n3 0.189974
R3329 XFAST.XSTART.NODEN XFAST.XSTART.NODEN.n5 0.1705
R3330 XFAST.XSTART.NODEN XFAST.XSTART.NODEN.n6 0.1505
R3331 XFAST.XSTART.NODEN.n5 XFAST.XSTART.NODEN.n2 0.0805
R3332 a_n31052_12300.n5 a_n31052_12300.n3 19.8938
R3333 a_n31052_12300.n5 a_n31052_12300.n4 19.1827
R3334 a_n31052_12300.n0 a_n31052_12300.t7 5.85122
R3335 a_n31052_12300.n11 a_n31052_12300.t4 5.85122
R3336 a_n31052_12300.n13 a_n31052_12300.n12 5.74202
R3337 a_n31052_12300.n7 a_n31052_12300.n6 4.59466
R3338 a_n31052_12300.n9 a_n31052_12300.n8 4.58471
R3339 a_n31052_12300.n11 a_n31052_12300.n10 4.5005
R3340 a_n31052_12300.n12 a_n31052_12300.n1 4.5005
R3341 a_n31052_12300.n6 a_n31052_12300.n0 4.5005
R3342 a_n31052_12300.n10 a_n31052_12300.n9 4.5005
R3343 a_n31052_12300.n2 a_n31052_12300.n1 4.5005
R3344 a_n31052_12300.n8 a_n31052_12300.n7 2.22546
R3345 a_n31052_12300.n3 a_n31052_12300.t1 0.3281
R3346 a_n31052_12300.n3 a_n31052_12300.t0 0.3281
R3347 a_n31052_12300.n4 a_n31052_12300.t2 0.3281
R3348 a_n31052_12300.n4 a_n31052_12300.t3 0.3281
R3349 a_n31052_12300.n8 a_n31052_12300.n5 0.219974
R3350 a_n31052_12300.n12 a_n31052_12300.n11 0.189974
R3351 a_n31052_12300.n12 a_n31052_12300.n0 0.189974
R3352 a_n31052_12300.n10 a_n31052_12300.n1 0.189974
R3353 a_n31052_12300.n6 a_n31052_12300.n1 0.189974
R3354 a_n31052_12300.n9 a_n31052_12300.n2 0.189974
R3355 a_n31052_12300.n13 a_n31052_12300.t5 0.1097
R3356 a_n31052_12300.t6 a_n31052_12300.n13 0.1097
R3357 a_n31052_12300.n7 a_n31052_12300.n2 0.092941
R3358 XFAST.XSTART.NODEP.n3 XFAST.XSTART.NODEP.t5 94.691
R3359 XFAST.XSTART.NODEP.n0 XFAST.XSTART.NODEP.t7 74.5104
R3360 XFAST.XSTART.NODEP.n0 XFAST.XSTART.NODEP.t8 74.5104
R3361 XFAST.XSTART.NODEP.n2 XFAST.XSTART.NODEP.t6 31.5274
R3362 XFAST.XSTART.NODEP XFAST.XSTART.NODEP.n0 26.0508
R3363 XFAST.XSTART.NODEP.n3 XFAST.XSTART.NODEP.t0 22.0076
R3364 XFAST.XSTART.NODEP XFAST.XSTART.NODEP.t4 19.1124
R3365 XFAST.XSTART.NODEP.n1 XFAST.XSTART.NODEP 17.29
R3366 XFAST.XSTART.NODEP.n1 XFAST.XSTART.NODEP 15.0663
R3367 XFAST.XSTART.NODEP.n4 XFAST.XSTART.NODEP.t1 10.9241
R3368 XFAST.XSTART.NODEP.n2 XFAST.XSTART.NODEP.n1 6.15839
R3369 XFAST.XSTART.NODEP.n6 XFAST.XSTART.NODEP.t2 5.69917
R3370 XFAST.XSTART.NODEP.n7 XFAST.XSTART.NODEP.t3 5.69917
R3371 XFAST.XSTART.NODEP.n4 XFAST.XSTART.NODEP.n3 4.80115
R3372 XFAST.XSTART.NODEP.n8 XFAST.XSTART.NODEP.n7 4.5005
R3373 XFAST.XSTART.NODEP.n6 XFAST.XSTART.NODEP.n5 4.5005
R3374 XFAST.XSTART.NODEP.n5 XFAST.XSTART.NODEP.n4 0.3205
R3375 XFAST.XSTART.NODEP.n7 XFAST.XSTART.NODEP.n6 0.189974
R3376 XFAST.XSTART.NODEP.n8 XFAST.XSTART.NODEP.n2 0.0805
R3377 XFAST.XSTART.NODEP.n5 XFAST.XSTART.NODEP.n2 0.0805
R3378 XFAST.XSTART.NODEP XFAST.XSTART.NODEP.n8 0.0405
R3379 a_27028_25200.n0 a_27028_25200.t1 16.0424
R3380 a_27028_25200.n0 a_27028_25200.t0 14.8582
R3381 a_27028_25200.n1 a_27028_25200.n0 6.02323
R3382 a_27028_25200.n1 a_27028_25200.t3 5.95154
R3383 a_27028_25200.t2 a_27028_25200.n1 5.95154
R3384 XGAIN.X2.INN.n5 XGAIN.X2.INN.t4 96.4943
R3385 XGAIN.X2.INN.n0 XGAIN.X2.INN.t6 74.5104
R3386 XGAIN.X2.INN.n0 XGAIN.X2.INN.t7 74.5104
R3387 XGAIN.X2.INN.n1 XGAIN.X2.INN.t5 35.6252
R3388 XGAIN.X2.INN.n5 XGAIN.X2.INN.t3 31.3566
R3389 XGAIN.X2.INN XGAIN.X2.INN.n0 26.0508
R3390 XGAIN.X2.INN.n1 XGAIN.X2.INN 23.4479
R3391 XGAIN.X2.INN.n5 XGAIN.X2.INN.t0 11.0041
R3392 XGAIN.X2.INN.n2 XGAIN.X2.INN.t2 5.69917
R3393 XGAIN.X2.INN.n3 XGAIN.X2.INN.t1 5.69917
R3394 XGAIN.X2.INN.n2 XGAIN.X2.INN.n1 4.5805
R3395 XGAIN.X2.INN.n4 XGAIN.X2.INN.n3 4.5005
R3396 XGAIN.X2.INN.n3 XGAIN.X2.INN.n2 0.189974
R3397 XGAIN.X2.INN XGAIN.X2.INN.n4 0.1705
R3398 XGAIN.X2.INN XGAIN.X2.INN.n5 0.1505
R3399 XGAIN.X2.INN.n4 XGAIN.X2.INN.n1 0.0805
R3400 a_24948_25100.n6 a_24948_25100.n4 19.8938
R3401 a_24948_25100.n6 a_24948_25100.n5 19.1827
R3402 a_24948_25100.t5 a_24948_25100.n13 5.60716
R3403 a_24948_25100.n2 a_24948_25100.t2 5.60716
R3404 a_24948_25100.n12 a_24948_25100.n1 5.44336
R3405 a_24948_25100.n7 a_24948_25100.n0 4.59466
R3406 a_24948_25100.n9 a_24948_25100.n8 4.58471
R3407 a_24948_25100.n10 a_24948_25100.n2 4.5005
R3408 a_24948_25100.n12 a_24948_25100.n11 4.5005
R3409 a_24948_25100.n13 a_24948_25100.n0 4.5005
R3410 a_24948_25100.n10 a_24948_25100.n9 4.5005
R3411 a_24948_25100.n11 a_24948_25100.n3 4.5005
R3412 a_24948_25100.n8 a_24948_25100.n7 2.22546
R3413 a_24948_25100.n8 a_24948_25100.n6 0.351553
R3414 a_24948_25100.n4 a_24948_25100.t7 0.3281
R3415 a_24948_25100.n4 a_24948_25100.t6 0.3281
R3416 a_24948_25100.n5 a_24948_25100.t1 0.3281
R3417 a_24948_25100.n5 a_24948_25100.t0 0.3281
R3418 a_24948_25100.n12 a_24948_25100.n2 0.189974
R3419 a_24948_25100.n13 a_24948_25100.n12 0.189974
R3420 a_24948_25100.n11 a_24948_25100.n10 0.189974
R3421 a_24948_25100.n11 a_24948_25100.n0 0.189974
R3422 a_24948_25100.n9 a_24948_25100.n3 0.189974
R3423 a_24948_25100.n1 a_24948_25100.t3 0.1643
R3424 a_24948_25100.n1 a_24948_25100.t4 0.1643
R3425 a_24948_25100.n7 a_24948_25100.n3 0.092941
R3426 XGAIN.X2.INP.n2 XGAIN.X2.INP.t4 94.691
R3427 XGAIN.X2.INP.n0 XGAIN.X2.INP.t6 74.5104
R3428 XGAIN.X2.INP.n0 XGAIN.X2.INP.t7 74.5104
R3429 XGAIN.X2.INP.n1 XGAIN.X2.INP.t5 35.6252
R3430 XGAIN.X2.INP XGAIN.X2.INP.n0 26.0508
R3431 XGAIN.X2.INP.n1 XGAIN.X2.INP 23.4479
R3432 XGAIN.X2.INP.n2 XGAIN.X2.INP.t2 21.9418
R3433 XGAIN.X2.INP.n3 XGAIN.X2.INP.t3 10.9241
R3434 XGAIN.X2.INP.n5 XGAIN.X2.INP.t1 5.69917
R3435 XGAIN.X2.INP.n6 XGAIN.X2.INP.t0 5.69917
R3436 XGAIN.X2.INP.n3 XGAIN.X2.INP.n2 4.80115
R3437 XGAIN.X2.INP.n7 XGAIN.X2.INP.n6 4.5005
R3438 XGAIN.X2.INP.n5 XGAIN.X2.INP.n4 4.5005
R3439 XGAIN.X2.INP.n4 XGAIN.X2.INP.n3 0.3205
R3440 XGAIN.X2.INP.n6 XGAIN.X2.INP.n5 0.189974
R3441 XGAIN.X2.INP.n7 XGAIN.X2.INP.n1 0.0805
R3442 XGAIN.X2.INP.n4 XGAIN.X2.INP.n1 0.0805
R3443 XGAIN.X2.INP XGAIN.X2.INP.n7 0.0405
R3444 a_n28972_25200.n0 a_n28972_25200.t0 16.0424
R3445 a_n28972_25200.n0 a_n28972_25200.t3 14.8582
R3446 a_n28972_25200.n1 a_n28972_25200.n0 5.90481
R3447 a_n28972_25200.n1 a_n28972_25200.t1 5.67287
R3448 a_n28972_25200.t2 a_n28972_25200.n1 5.67287
R3449 XFAST.X2.INN.n5 XFAST.X2.INN.t4 96.4943
R3450 XFAST.X2.INN.n0 XFAST.X2.INN.t6 74.5104
R3451 XFAST.X2.INN.n0 XFAST.X2.INN.t7 74.5104
R3452 XFAST.X2.INN.n1 XFAST.X2.INN.t5 31.5274
R3453 XFAST.X2.INN.n5 XFAST.X2.INN.t0 31.4224
R3454 XFAST.X2.INN XFAST.X2.INN.n0 26.0508
R3455 XFAST.X2.INN.n1 XFAST.X2.INN 23.4479
R3456 XFAST.X2.INN.n5 XFAST.X2.INN.t3 11.0041
R3457 XFAST.X2.INN.n2 XFAST.X2.INN.t2 5.69917
R3458 XFAST.X2.INN.n3 XFAST.X2.INN.t1 5.69917
R3459 XFAST.X2.INN.n2 XFAST.X2.INN.n1 4.5805
R3460 XFAST.X2.INN.n4 XFAST.X2.INN.n3 4.5005
R3461 XFAST.X2.INN.n3 XFAST.X2.INN.n2 0.189974
R3462 XFAST.X2.INN XFAST.X2.INN.n4 0.1705
R3463 XFAST.X2.INN XFAST.X2.INN.n5 0.1505
R3464 XFAST.X2.INN.n4 XFAST.X2.INN.n1 0.0805
R3465 a_n31052_25100.n6 a_n31052_25100.n4 19.8938
R3466 a_n31052_25100.n6 a_n31052_25100.n5 19.1827
R3467 a_n31052_25100.t5 a_n31052_25100.n13 5.85122
R3468 a_n31052_25100.n2 a_n31052_25100.t2 5.85122
R3469 a_n31052_25100.n12 a_n31052_25100.n1 5.74202
R3470 a_n31052_25100.n7 a_n31052_25100.n0 4.59466
R3471 a_n31052_25100.n9 a_n31052_25100.n8 4.58471
R3472 a_n31052_25100.n10 a_n31052_25100.n2 4.5005
R3473 a_n31052_25100.n12 a_n31052_25100.n11 4.5005
R3474 a_n31052_25100.n13 a_n31052_25100.n0 4.5005
R3475 a_n31052_25100.n10 a_n31052_25100.n9 4.5005
R3476 a_n31052_25100.n11 a_n31052_25100.n3 4.5005
R3477 a_n31052_25100.n8 a_n31052_25100.n7 2.22546
R3478 a_n31052_25100.n4 a_n31052_25100.t6 0.3281
R3479 a_n31052_25100.n4 a_n31052_25100.t7 0.3281
R3480 a_n31052_25100.n5 a_n31052_25100.t1 0.3281
R3481 a_n31052_25100.n5 a_n31052_25100.t0 0.3281
R3482 a_n31052_25100.n8 a_n31052_25100.n6 0.219974
R3483 a_n31052_25100.n12 a_n31052_25100.n2 0.189974
R3484 a_n31052_25100.n13 a_n31052_25100.n12 0.189974
R3485 a_n31052_25100.n11 a_n31052_25100.n10 0.189974
R3486 a_n31052_25100.n11 a_n31052_25100.n0 0.189974
R3487 a_n31052_25100.n9 a_n31052_25100.n3 0.189974
R3488 a_n31052_25100.n1 a_n31052_25100.t3 0.1097
R3489 a_n31052_25100.n1 a_n31052_25100.t4 0.1097
R3490 a_n31052_25100.n7 a_n31052_25100.n3 0.092941
R3491 XFAST.X2.INP.n2 XFAST.X2.INP.t4 94.691
R3492 XFAST.X2.INP.n0 XFAST.X2.INP.t6 74.5104
R3493 XFAST.X2.INP.n0 XFAST.X2.INP.t7 74.5104
R3494 XFAST.X2.INP.n1 XFAST.X2.INP.t5 31.5274
R3495 XFAST.X2.INP XFAST.X2.INP.n0 26.0508
R3496 XFAST.X2.INP.n1 XFAST.X2.INP 23.4479
R3497 XFAST.X2.INP.n2 XFAST.X2.INP.t0 22.0076
R3498 XFAST.X2.INP.n3 XFAST.X2.INP.t3 10.9241
R3499 XFAST.X2.INP.n5 XFAST.X2.INP.t2 5.69917
R3500 XFAST.X2.INP.n6 XFAST.X2.INP.t1 5.69917
R3501 XFAST.X2.INP.n3 XFAST.X2.INP.n2 4.80115
R3502 XFAST.X2.INP.n7 XFAST.X2.INP.n6 4.5005
R3503 XFAST.X2.INP.n5 XFAST.X2.INP.n4 4.5005
R3504 XFAST.X2.INP.n4 XFAST.X2.INP.n3 0.3205
R3505 XFAST.X2.INP.n6 XFAST.X2.INP.n5 0.189974
R3506 XFAST.X2.INP.n7 XFAST.X2.INP.n1 0.0805
R3507 XFAST.X2.INP.n4 XFAST.X2.INP.n1 0.0805
R3508 XFAST.X2.INP XFAST.X2.INP.n7 0.0405
R3509 a_27028_38000.n0 a_27028_38000.t0 16.0424
R3510 a_27028_38000.n0 a_27028_38000.t1 14.8582
R3511 a_27028_38000.n1 a_27028_38000.n0 6.02323
R3512 a_27028_38000.n1 a_27028_38000.t3 5.95154
R3513 a_27028_38000.t2 a_27028_38000.n1 5.95154
R3514 XGAIN.XBUF.INN.n7 XGAIN.XBUF.INN.t6 96.4943
R3515 XGAIN.XBUF.INN.n1 XGAIN.XBUF.INN.t8 74.5104
R3516 XGAIN.XBUF.INN.n1 XGAIN.XBUF.INN.t9 74.5104
R3517 XGAIN.XBUF.INN.n0 XGAIN.XBUF.INN.t4 74.5104
R3518 XGAIN.XBUF.INN.n0 XGAIN.XBUF.INN.t5 74.5104
R3519 XGAIN.XBUF.INN.n3 XGAIN.XBUF.INN.t7 35.6252
R3520 XGAIN.XBUF.INN.n7 XGAIN.XBUF.INN.t0 31.3566
R3521 XGAIN.XBUF.INN XGAIN.XBUF.INN.n1 26.0508
R3522 XGAIN.XBUF.INN XGAIN.XBUF.INN.n0 26.0508
R3523 XGAIN.XBUF.INN.n2 XGAIN.XBUF.INN 24.711
R3524 XGAIN.XBUF.INN.n2 XGAIN.XBUF.INN 17.29
R3525 XGAIN.XBUF.INN.n7 XGAIN.XBUF.INN.t1 11.0041
R3526 XGAIN.XBUF.INN.n3 XGAIN.XBUF.INN.n2 6.15839
R3527 XGAIN.XBUF.INN.n4 XGAIN.XBUF.INN.t3 5.69917
R3528 XGAIN.XBUF.INN.n5 XGAIN.XBUF.INN.t2 5.69917
R3529 XGAIN.XBUF.INN.n4 XGAIN.XBUF.INN.n3 4.5805
R3530 XGAIN.XBUF.INN.n6 XGAIN.XBUF.INN.n5 4.5005
R3531 XGAIN.XBUF.INN.n5 XGAIN.XBUF.INN.n4 0.189974
R3532 XGAIN.XBUF.INN XGAIN.XBUF.INN.n6 0.1705
R3533 XGAIN.XBUF.INN XGAIN.XBUF.INN.n7 0.1505
R3534 XGAIN.XBUF.INN.n6 XGAIN.XBUF.INN.n3 0.0805
R3535 a_24948_37900.n6 a_24948_37900.n4 19.8938
R3536 a_24948_37900.n6 a_24948_37900.n5 19.1827
R3537 a_24948_37900.t5 a_24948_37900.n13 5.60716
R3538 a_24948_37900.n2 a_24948_37900.t2 5.60716
R3539 a_24948_37900.n12 a_24948_37900.n1 5.44336
R3540 a_24948_37900.n7 a_24948_37900.n0 4.59466
R3541 a_24948_37900.n9 a_24948_37900.n8 4.58471
R3542 a_24948_37900.n10 a_24948_37900.n2 4.5005
R3543 a_24948_37900.n12 a_24948_37900.n11 4.5005
R3544 a_24948_37900.n13 a_24948_37900.n0 4.5005
R3545 a_24948_37900.n10 a_24948_37900.n9 4.5005
R3546 a_24948_37900.n11 a_24948_37900.n3 4.5005
R3547 a_24948_37900.n8 a_24948_37900.n7 2.22546
R3548 a_24948_37900.n8 a_24948_37900.n6 0.351553
R3549 a_24948_37900.n4 a_24948_37900.t7 0.3281
R3550 a_24948_37900.n4 a_24948_37900.t6 0.3281
R3551 a_24948_37900.n5 a_24948_37900.t1 0.3281
R3552 a_24948_37900.n5 a_24948_37900.t0 0.3281
R3553 a_24948_37900.n12 a_24948_37900.n2 0.189974
R3554 a_24948_37900.n13 a_24948_37900.n12 0.189974
R3555 a_24948_37900.n11 a_24948_37900.n10 0.189974
R3556 a_24948_37900.n11 a_24948_37900.n0 0.189974
R3557 a_24948_37900.n9 a_24948_37900.n3 0.189974
R3558 a_24948_37900.n1 a_24948_37900.t3 0.1643
R3559 a_24948_37900.n1 a_24948_37900.t4 0.1643
R3560 a_24948_37900.n7 a_24948_37900.n3 0.092941
R3561 XGAIN.XBUF.INP.n4 XGAIN.XBUF.INP.t6 94.691
R3562 XGAIN.XBUF.INP.n0 XGAIN.XBUF.INP.t4 74.5104
R3563 XGAIN.XBUF.INP.n0 XGAIN.XBUF.INP.t5 74.5104
R3564 XGAIN.XBUF.INP.n1 XGAIN.XBUF.INP.t8 74.5104
R3565 XGAIN.XBUF.INP.n1 XGAIN.XBUF.INP.t9 74.5104
R3566 XGAIN.XBUF.INP.n3 XGAIN.XBUF.INP.t7 35.6252
R3567 XGAIN.XBUF.INP XGAIN.XBUF.INP.n0 26.0508
R3568 XGAIN.XBUF.INP XGAIN.XBUF.INP.n1 26.0508
R3569 XGAIN.XBUF.INP.n2 XGAIN.XBUF.INP 24.711
R3570 XGAIN.XBUF.INP.n4 XGAIN.XBUF.INP.t0 21.9418
R3571 XGAIN.XBUF.INP.n2 XGAIN.XBUF.INP 17.29
R3572 XGAIN.XBUF.INP.n5 XGAIN.XBUF.INP.t1 10.9241
R3573 XGAIN.XBUF.INP.n3 XGAIN.XBUF.INP.n2 6.15839
R3574 XGAIN.XBUF.INP.n7 XGAIN.XBUF.INP.t3 5.69917
R3575 XGAIN.XBUF.INP.n8 XGAIN.XBUF.INP.t2 5.69917
R3576 XGAIN.XBUF.INP.n5 XGAIN.XBUF.INP.n4 4.80115
R3577 XGAIN.XBUF.INP.n9 XGAIN.XBUF.INP.n8 4.5005
R3578 XGAIN.XBUF.INP.n7 XGAIN.XBUF.INP.n6 4.5005
R3579 XGAIN.XBUF.INP.n6 XGAIN.XBUF.INP.n5 0.3205
R3580 XGAIN.XBUF.INP.n8 XGAIN.XBUF.INP.n7 0.189974
R3581 XGAIN.XBUF.INP.n9 XGAIN.XBUF.INP.n3 0.0805
R3582 XGAIN.XBUF.INP.n6 XGAIN.XBUF.INP.n3 0.0805
R3583 XGAIN.XBUF.INP XGAIN.XBUF.INP.n9 0.0405
R3584 a_n28972_38000.n0 a_n28972_38000.t0 16.0424
R3585 a_n28972_38000.n0 a_n28972_38000.t3 14.8582
R3586 a_n28972_38000.n1 a_n28972_38000.n0 5.90481
R3587 a_n28972_38000.n1 a_n28972_38000.t1 5.67287
R3588 a_n28972_38000.t2 a_n28972_38000.n1 5.67287
R3589 XFAST.XBUF.INN.n7 XFAST.XBUF.INN.t6 96.4943
R3590 XFAST.XBUF.INN.n1 XFAST.XBUF.INN.t8 74.5104
R3591 XFAST.XBUF.INN.n1 XFAST.XBUF.INN.t9 74.5104
R3592 XFAST.XBUF.INN.n0 XFAST.XBUF.INN.t4 74.5104
R3593 XFAST.XBUF.INN.n0 XFAST.XBUF.INN.t5 74.5104
R3594 XFAST.XBUF.INN.n3 XFAST.XBUF.INN.t7 31.5274
R3595 XFAST.XBUF.INN.n7 XFAST.XBUF.INN.t0 31.4224
R3596 XFAST.XBUF.INN XFAST.XBUF.INN.n1 26.0508
R3597 XFAST.XBUF.INN XFAST.XBUF.INN.n0 26.0508
R3598 XFAST.XBUF.INN.n2 XFAST.XBUF.INN 24.711
R3599 XFAST.XBUF.INN.n2 XFAST.XBUF.INN 17.29
R3600 XFAST.XBUF.INN.n7 XFAST.XBUF.INN.t1 11.0041
R3601 XFAST.XBUF.INN.n3 XFAST.XBUF.INN.n2 6.15839
R3602 XFAST.XBUF.INN.n4 XFAST.XBUF.INN.t3 5.69917
R3603 XFAST.XBUF.INN.n5 XFAST.XBUF.INN.t2 5.69917
R3604 XFAST.XBUF.INN.n4 XFAST.XBUF.INN.n3 4.5805
R3605 XFAST.XBUF.INN.n6 XFAST.XBUF.INN.n5 4.5005
R3606 XFAST.XBUF.INN.n5 XFAST.XBUF.INN.n4 0.189974
R3607 XFAST.XBUF.INN XFAST.XBUF.INN.n6 0.1705
R3608 XFAST.XBUF.INN XFAST.XBUF.INN.n7 0.1505
R3609 XFAST.XBUF.INN.n6 XFAST.XBUF.INN.n3 0.0805
R3610 a_n31052_37900.n6 a_n31052_37900.n4 19.8938
R3611 a_n31052_37900.n6 a_n31052_37900.n5 19.1827
R3612 a_n31052_37900.t5 a_n31052_37900.n13 5.85122
R3613 a_n31052_37900.n2 a_n31052_37900.t2 5.85122
R3614 a_n31052_37900.n12 a_n31052_37900.n1 5.74202
R3615 a_n31052_37900.n7 a_n31052_37900.n0 4.59466
R3616 a_n31052_37900.n9 a_n31052_37900.n8 4.58471
R3617 a_n31052_37900.n10 a_n31052_37900.n2 4.5005
R3618 a_n31052_37900.n12 a_n31052_37900.n11 4.5005
R3619 a_n31052_37900.n13 a_n31052_37900.n0 4.5005
R3620 a_n31052_37900.n10 a_n31052_37900.n9 4.5005
R3621 a_n31052_37900.n11 a_n31052_37900.n3 4.5005
R3622 a_n31052_37900.n8 a_n31052_37900.n7 2.22546
R3623 a_n31052_37900.n4 a_n31052_37900.t6 0.3281
R3624 a_n31052_37900.n4 a_n31052_37900.t7 0.3281
R3625 a_n31052_37900.n5 a_n31052_37900.t0 0.3281
R3626 a_n31052_37900.n5 a_n31052_37900.t1 0.3281
R3627 a_n31052_37900.n8 a_n31052_37900.n6 0.219974
R3628 a_n31052_37900.n12 a_n31052_37900.n2 0.189974
R3629 a_n31052_37900.n13 a_n31052_37900.n12 0.189974
R3630 a_n31052_37900.n11 a_n31052_37900.n10 0.189974
R3631 a_n31052_37900.n11 a_n31052_37900.n0 0.189974
R3632 a_n31052_37900.n9 a_n31052_37900.n3 0.189974
R3633 a_n31052_37900.n1 a_n31052_37900.t3 0.1097
R3634 a_n31052_37900.n1 a_n31052_37900.t4 0.1097
R3635 a_n31052_37900.n7 a_n31052_37900.n3 0.092941
R3636 XFAST.XBUF.INP.n4 XFAST.XBUF.INP.t6 94.691
R3637 XFAST.XBUF.INP.n0 XFAST.XBUF.INP.t4 74.5104
R3638 XFAST.XBUF.INP.n0 XFAST.XBUF.INP.t5 74.5104
R3639 XFAST.XBUF.INP.n1 XFAST.XBUF.INP.t8 74.5104
R3640 XFAST.XBUF.INP.n1 XFAST.XBUF.INP.t9 74.5104
R3641 XFAST.XBUF.INP.n3 XFAST.XBUF.INP.t7 31.5274
R3642 XFAST.XBUF.INP XFAST.XBUF.INP.n0 26.0508
R3643 XFAST.XBUF.INP XFAST.XBUF.INP.n1 26.0508
R3644 XFAST.XBUF.INP.n2 XFAST.XBUF.INP 24.711
R3645 XFAST.XBUF.INP.n4 XFAST.XBUF.INP.t0 22.0076
R3646 XFAST.XBUF.INP.n2 XFAST.XBUF.INP 17.29
R3647 XFAST.XBUF.INP.n5 XFAST.XBUF.INP.t3 10.9241
R3648 XFAST.XBUF.INP.n3 XFAST.XBUF.INP.n2 6.15839
R3649 XFAST.XBUF.INP.n7 XFAST.XBUF.INP.t2 5.69917
R3650 XFAST.XBUF.INP.n8 XFAST.XBUF.INP.t1 5.69917
R3651 XFAST.XBUF.INP.n5 XFAST.XBUF.INP.n4 4.80115
R3652 XFAST.XBUF.INP.n9 XFAST.XBUF.INP.n8 4.5005
R3653 XFAST.XBUF.INP.n7 XFAST.XBUF.INP.n6 4.5005
R3654 XFAST.XBUF.INP.n6 XFAST.XBUF.INP.n5 0.3205
R3655 XFAST.XBUF.INP.n8 XFAST.XBUF.INP.n7 0.189974
R3656 XFAST.XBUF.INP.n9 XFAST.XBUF.INP.n3 0.0805
R3657 XFAST.XBUF.INP.n6 XFAST.XBUF.INP.n3 0.0805
R3658 XFAST.XBUF.INP XFAST.XBUF.INP.n9 0.0405
R3659 a_1748_53500.n5 a_1748_53500.n3 10.5451
R3660 a_1748_53500.n8 a_1748_53500.n6 10.5451
R3661 a_1748_53500.n5 a_1748_53500.n4 10.1451
R3662 a_1748_53500.n8 a_1748_53500.n7 10.1451
R3663 a_1748_53500.t5 a_1748_53500.n11 6.55182
R3664 a_1748_53500.n2 a_1748_53500.t2 6.45713
R3665 a_1748_53500.n1 a_1748_53500.n0 6.29333
R3666 a_1748_53500.n10 a_1748_53500.n2 4.63668
R3667 a_1748_53500.n11 a_1748_53500.n10 2.23814
R3668 a_1748_53500.n10 a_1748_53500.n9 0.6055
R3669 a_1748_53500.n3 a_1748_53500.t9 0.3281
R3670 a_1748_53500.n3 a_1748_53500.t8 0.3281
R3671 a_1748_53500.n4 a_1748_53500.t1 0.3281
R3672 a_1748_53500.n4 a_1748_53500.t0 0.3281
R3673 a_1748_53500.n7 a_1748_53500.t10 0.3281
R3674 a_1748_53500.n7 a_1748_53500.t7 0.3281
R3675 a_1748_53500.n6 a_1748_53500.t11 0.3281
R3676 a_1748_53500.n6 a_1748_53500.t6 0.3281
R3677 a_1748_53500.n9 a_1748_53500.n8 0.2005
R3678 a_1748_53500.n9 a_1748_53500.n5 0.2005
R3679 a_1748_53500.n2 a_1748_53500.n1 0.189974
R3680 a_1748_53500.n0 a_1748_53500.t3 0.1643
R3681 a_1748_53500.n0 a_1748_53500.t4 0.1643
R3682 a_1748_53500.n11 a_1748_53500.n1 0.0924286
R3683 a_n4252_53500.n5 a_n4252_53500.n0 15.0138
R3684 a_n4252_53500.n4 a_n4252_53500.n2 15.0138
R3685 a_n4252_53500.n5 a_n4252_53500.n1 14.6138
R3686 a_n4252_53500.n4 a_n4252_53500.n3 14.6138
R3687 a_n4252_53500.n6 a_n4252_53500.n5 6.3955
R3688 a_n4252_53500.n8 a_n4252_53500.t7 6.06762
R3689 a_n4252_53500.t10 a_n4252_53500.n10 5.97267
R3690 a_n4252_53500.n9 a_n4252_53500.n7 5.64507
R3691 a_n4252_53500.n10 a_n4252_53500.n6 4.5005
R3692 a_n4252_53500.n8 a_n4252_53500.n6 2.40435
R3693 a_n4252_53500.n5 a_n4252_53500.n4 0.4005
R3694 a_n4252_53500.n7 a_n4252_53500.t8 0.3281
R3695 a_n4252_53500.n7 a_n4252_53500.t9 0.3281
R3696 a_n4252_53500.n0 a_n4252_53500.t5 0.3281
R3697 a_n4252_53500.n0 a_n4252_53500.t3 0.3281
R3698 a_n4252_53500.n1 a_n4252_53500.t4 0.3281
R3699 a_n4252_53500.n1 a_n4252_53500.t11 0.3281
R3700 a_n4252_53500.n3 a_n4252_53500.t1 0.3281
R3701 a_n4252_53500.n3 a_n4252_53500.t6 0.3281
R3702 a_n4252_53500.n2 a_n4252_53500.t2 0.3281
R3703 a_n4252_53500.n2 a_n4252_53500.t0 0.3281
R3704 a_n4252_53500.n10 a_n4252_53500.n9 0.189974
R3705 a_n4252_53500.n9 a_n4252_53500.n8 0.0921777
R3706 a_n5852_53500.n4 a_n5852_53500.n2 19.2915
R3707 a_n5852_53500.n7 a_n5852_53500.n5 19.2915
R3708 a_n5852_53500.n4 a_n5852_53500.n3 19.1138
R3709 a_n5852_53500.n7 a_n5852_53500.n6 19.1138
R3710 a_n5852_53500.n10 a_n5852_53500.n8 9.3805
R3711 a_n5852_53500.t9 a_n5852_53500.n11 6.0679
R3712 a_n5852_53500.n9 a_n5852_53500.t6 5.97267
R3713 a_n5852_53500.n1 a_n5852_53500.n0 5.64507
R3714 a_n5852_53500.n10 a_n5852_53500.n9 4.68997
R3715 a_n5852_53500.n11 a_n5852_53500.n10 2.251
R3716 a_n5852_53500.n8 a_n5852_53500.n7 0.444944
R3717 a_n5852_53500.n8 a_n5852_53500.n4 0.444944
R3718 a_n5852_53500.n0 a_n5852_53500.t7 0.3281
R3719 a_n5852_53500.n0 a_n5852_53500.t8 0.3281
R3720 a_n5852_53500.n2 a_n5852_53500.t5 0.3281
R3721 a_n5852_53500.n2 a_n5852_53500.t10 0.3281
R3722 a_n5852_53500.n3 a_n5852_53500.t0 0.3281
R3723 a_n5852_53500.n3 a_n5852_53500.t1 0.3281
R3724 a_n5852_53500.n6 a_n5852_53500.t11 0.3281
R3725 a_n5852_53500.n6 a_n5852_53500.t4 0.3281
R3726 a_n5852_53500.n5 a_n5852_53500.t2 0.3281
R3727 a_n5852_53500.n5 a_n5852_53500.t3 0.3281
R3728 a_n5852_53500.n9 a_n5852_53500.n1 0.189974
R3729 a_n5852_53500.n11 a_n5852_53500.n1 0.0919091
R3730 XSEL.A_N.n8 XSEL.A_N.t4 96.4943
R3731 XSEL.A_N.n1 XSEL.A_N.t6 74.5242
R3732 XSEL.A_N.n2 XSEL.A_N.t9 74.5242
R3733 XSEL.A_N.n1 XSEL.A_N.t7 74.4955
R3734 XSEL.A_N.n2 XSEL.A_N.t8 74.4955
R3735 XSEL.A_N.n4 XSEL.A_N 53.0695
R3736 XSEL.A_N.n0 XSEL.A_N.t5 31.5274
R3737 XSEL.A_N.n8 XSEL.A_N.t3 31.4224
R3738 XSEL.A_N XSEL.A_N.n3 19.2531
R3739 XSEL.A_N.n8 XSEL.A_N.t0 11.0041
R3740 XSEL.A_N.n3 XSEL.A_N.n1 7.28487
R3741 XSEL.A_N.n3 XSEL.A_N.n2 7.28487
R3742 XSEL.A_N.n5 XSEL.A_N.t2 5.69917
R3743 XSEL.A_N.n6 XSEL.A_N.t1 5.69917
R3744 XSEL.A_N.n7 XSEL.A_N.n6 4.5005
R3745 XSEL.A_N.n5 XSEL.A_N.n4 4.5005
R3746 XSEL.A_N.n6 XSEL.A_N.n5 0.189974
R3747 XSEL.A_N XSEL.A_N.n7 0.1705
R3748 XSEL.A_N XSEL.A_N.n8 0.1505
R3749 XSEL.A_N.n7 XSEL.A_N.n0 0.0805
R3750 XSEL.A_N.n4 XSEL.A_N.n0 0.0805
R3751 XSEL.B_N.n8 XSEL.B_N.t4 96.4943
R3752 XSEL.B_N.n1 XSEL.B_N.t6 74.5242
R3753 XSEL.B_N.n2 XSEL.B_N.t9 74.5242
R3754 XSEL.B_N.n1 XSEL.B_N.t7 74.4955
R3755 XSEL.B_N.n2 XSEL.B_N.t8 74.4955
R3756 XSEL.B_N.n4 XSEL.B_N 49.6352
R3757 XSEL.B_N.n0 XSEL.B_N.t5 35.6252
R3758 XSEL.B_N.n8 XSEL.B_N.t3 31.3566
R3759 XSEL.B_N XSEL.B_N.n3 19.2531
R3760 XSEL.B_N.n8 XSEL.B_N.t0 11.0041
R3761 XSEL.B_N.n3 XSEL.B_N.n1 7.28487
R3762 XSEL.B_N.n3 XSEL.B_N.n2 7.28487
R3763 XSEL.B_N.n5 XSEL.B_N.t2 5.69917
R3764 XSEL.B_N.n6 XSEL.B_N.t1 5.69917
R3765 XSEL.B_N.n7 XSEL.B_N.n6 4.5005
R3766 XSEL.B_N.n5 XSEL.B_N.n4 4.5005
R3767 XSEL.B_N.n6 XSEL.B_N.n5 0.189974
R3768 XSEL.B_N XSEL.B_N.n7 0.1705
R3769 XSEL.B_N XSEL.B_N.n8 0.1505
R3770 XSEL.B_N.n7 XSEL.B_N.n0 0.0805
R3771 XSEL.B_N.n4 XSEL.B_N.n0 0.0805
R3772 XSEL.B_P.n4 XSEL.B_P.t4 94.691
R3773 XSEL.B_P.n0 XSEL.B_P.t6 74.5242
R3774 XSEL.B_P.n1 XSEL.B_P.t9 74.5242
R3775 XSEL.B_P.n0 XSEL.B_P.t7 74.4955
R3776 XSEL.B_P.n1 XSEL.B_P.t8 74.4955
R3777 XSEL.B_P.n3 XSEL.B_P.t5 35.6252
R3778 XSEL.B_P.n4 XSEL.B_P.t1 21.9418
R3779 XSEL.B_P XSEL.B_P.n2 19.2531
R3780 XSEL.B_P.n5 XSEL.B_P.t0 10.9241
R3781 XSEL.B_P.n2 XSEL.B_P.n0 7.28487
R3782 XSEL.B_P.n2 XSEL.B_P.n1 7.28487
R3783 XSEL.B_P.n7 XSEL.B_P.t3 5.69917
R3784 XSEL.B_P.n8 XSEL.B_P.t2 5.69917
R3785 XSEL.B_P.n5 XSEL.B_P.n4 4.80115
R3786 XSEL.B_P.n9 XSEL.B_P.n8 4.5005
R3787 XSEL.B_P.n7 XSEL.B_P.n6 4.5005
R3788 XSEL.B_P.n6 XSEL.B_P.n5 0.3205
R3789 XSEL.B_P.n8 XSEL.B_P.n7 0.189974
R3790 XSEL.B_P.n9 XSEL.B_P.n3 0.0805
R3791 XSEL.B_P.n6 XSEL.B_P.n3 0.0805
R3792 XSEL.B_P XSEL.B_P.n9 0.0405
R3793 XSEL.A_P.n4 XSEL.A_P.t4 94.691
R3794 XSEL.A_P.n0 XSEL.A_P.t6 74.5242
R3795 XSEL.A_P.n1 XSEL.A_P.t9 74.5242
R3796 XSEL.A_P.n0 XSEL.A_P.t7 74.4955
R3797 XSEL.A_P.n1 XSEL.A_P.t8 74.4955
R3798 XSEL.A_P.n3 XSEL.A_P.t5 31.5274
R3799 XSEL.A_P.n4 XSEL.A_P.t3 22.0076
R3800 XSEL.A_P XSEL.A_P.n2 19.2531
R3801 XSEL.A_P.n5 XSEL.A_P.t2 10.9241
R3802 XSEL.A_P.n2 XSEL.A_P.n0 7.28487
R3803 XSEL.A_P.n2 XSEL.A_P.n1 7.28487
R3804 XSEL.A_P.n7 XSEL.A_P.t1 5.69917
R3805 XSEL.A_P.n8 XSEL.A_P.t0 5.69917
R3806 XSEL.A_P.n5 XSEL.A_P.n4 4.80115
R3807 XSEL.A_P.n9 XSEL.A_P.n8 4.5005
R3808 XSEL.A_P.n7 XSEL.A_P.n6 4.5005
R3809 XSEL.A_P.n6 XSEL.A_P.n5 0.3205
R3810 XSEL.A_P.n8 XSEL.A_P.n7 0.189974
R3811 XSEL.A_P.n9 XSEL.A_P.n3 0.0805
R3812 XSEL.A_P.n6 XSEL.A_P.n3 0.0805
R3813 XSEL.A_P XSEL.A_P.n9 0.0405
R3814 a_n2796_53500.n0 a_n2796_53500.t9 74.5242
R3815 a_n2796_53500.n1 a_n2796_53500.t12 74.5242
R3816 a_n2796_53500.n0 a_n2796_53500.t10 74.4955
R3817 a_n2796_53500.n1 a_n2796_53500.t11 74.4955
R3818 a_n2796_53500.n3 a_n2796_53500.n2 21.8397
R3819 a_n2796_53500.n3 a_n2796_53500.t8 12.772
R3820 a_n2796_53500.n2 a_n2796_53500.n0 7.28371
R3821 a_n2796_53500.n2 a_n2796_53500.n1 7.28371
R3822 a_n2796_53500.n4 a_n2796_53500.t7 6.0676
R3823 a_n2796_53500.n11 a_n2796_53500.t0 6.0676
R3824 a_n2796_53500.n4 a_n2796_53500.t6 6.06436
R3825 a_n2796_53500.n11 a_n2796_53500.t1 6.06436
R3826 a_n2796_53500.t3 a_n2796_53500.n14 5.97267
R3827 a_n2796_53500.n6 a_n2796_53500.t5 5.97267
R3828 a_n2796_53500.n7 a_n2796_53500.t4 5.97267
R3829 a_n2796_53500.n13 a_n2796_53500.t2 5.97267
R3830 a_n2796_53500.n13 a_n2796_53500.n12 4.5005
R3831 a_n2796_53500.n14 a_n2796_53500.n10 4.5005
R3832 a_n2796_53500.n8 a_n2796_53500.n7 4.5005
R3833 a_n2796_53500.n6 a_n2796_53500.n5 4.5005
R3834 a_n2796_53500.n12 a_n2796_53500.n11 2.48391
R3835 a_n2796_53500.n5 a_n2796_53500.n4 2.48391
R3836 a_n2796_53500.n9 a_n2796_53500.n3 0.8055
R3837 a_n2796_53500.n14 a_n2796_53500.n13 0.189974
R3838 a_n2796_53500.n7 a_n2796_53500.n6 0.189974
R3839 a_n2796_53500.n12 a_n2796_53500.n10 0.1605
R3840 a_n2796_53500.n8 a_n2796_53500.n5 0.1605
R3841 a_n2796_53500.n10 a_n2796_53500.n9 0.1205
R3842 a_n2796_53500.n9 a_n2796_53500.n8 0.1205
R3843 a_n5996_53500.n0 a_n5996_53500.t9 74.5242
R3844 a_n5996_53500.n1 a_n5996_53500.t12 74.5242
R3845 a_n5996_53500.n0 a_n5996_53500.t10 74.4955
R3846 a_n5996_53500.n1 a_n5996_53500.t11 74.4955
R3847 a_n5996_53500.n3 a_n5996_53500.n2 29.0226
R3848 a_n5996_53500.n3 a_n5996_53500.t0 12.972
R3849 a_n5996_53500.n2 a_n5996_53500.n0 7.28371
R3850 a_n5996_53500.n2 a_n5996_53500.n1 7.28371
R3851 a_n5996_53500.n4 a_n5996_53500.t8 6.0676
R3852 a_n5996_53500.n11 a_n5996_53500.t1 6.0676
R3853 a_n5996_53500.n4 a_n5996_53500.t7 6.06436
R3854 a_n5996_53500.n11 a_n5996_53500.t2 6.06436
R3855 a_n5996_53500.t4 a_n5996_53500.n14 5.97267
R3856 a_n5996_53500.n6 a_n5996_53500.t6 5.97267
R3857 a_n5996_53500.n7 a_n5996_53500.t5 5.97267
R3858 a_n5996_53500.n13 a_n5996_53500.t3 5.97267
R3859 a_n5996_53500.n13 a_n5996_53500.n12 4.5005
R3860 a_n5996_53500.n14 a_n5996_53500.n10 4.5005
R3861 a_n5996_53500.n8 a_n5996_53500.n7 4.5005
R3862 a_n5996_53500.n6 a_n5996_53500.n5 4.5005
R3863 a_n5996_53500.n12 a_n5996_53500.n11 2.48391
R3864 a_n5996_53500.n5 a_n5996_53500.n4 2.48391
R3865 a_n5996_53500.n9 a_n5996_53500.n3 0.6055
R3866 a_n5996_53500.n14 a_n5996_53500.n13 0.189974
R3867 a_n5996_53500.n7 a_n5996_53500.n6 0.189974
R3868 a_n5996_53500.n12 a_n5996_53500.n10 0.1605
R3869 a_n5996_53500.n8 a_n5996_53500.n5 0.1605
R3870 a_n5996_53500.n10 a_n5996_53500.n9 0.1205
R3871 a_n5996_53500.n9 a_n5996_53500.n8 0.1205
C0 XGAIN.X2.INP XGDAC.CTRL_A 0.15638f
C1 a_32500_n24800# a_28800_n29600# 0.20075f
C2 SEL_B XSEL.B_P 0.02033f
C3 VREFL F_B3B 0.25739f
C4 G_B0B G_B0 0.12533f
C5 XGAIN.XBUF.INP XGAIN.XBUF.INN 0.86001f
C6 VDD XSEL.A_P 1.93276f
C7 GAIN_KICKP GAIN_KICKN 0.13731f
C8 XSEL.A_P XFAST.XBUF.INP 0.1833f
C9 XSEL.A_P XSEL.A_N 3.59127f
C10 F_B4B F_B4 0.12533f
C11 XGAIN.XSTART.NODEP XGAIN.X2.INP 0.18726f
C12 XFAST.XSTART.NODEN XFAST.XBUF.INN 4.36587f
C13 XFAST.XSTART.NODEP XFDAC.CTRL_A 0.27417f
C14 a_n32900_n28902# a_n35900_n28902# 0.20075f
C15 VREFL G_A1B 0.25739f
C16 G_A2 G_A2B 0.12533f
C17 XGAIN.XBUF.INP XGDAC.CTRL_A 0.31276f
C18 VDD XGAIN.X2.INP 0.48219f
C19 VREFL F_B4B 0.25739f
C20 XFAST.XSTART.NODEN XFDAC.CTRL_A 0.41927f
C21 XGAIN.XBUF.INN XGDAC.CTRL_A 0.65519f
C22 SEL_BUF SEL_B 0.22922f
C23 a_20100_n28902# a_23100_n28902# 0.20075f
C24 XGAIN.XBUF.INN XSEL.B_N 0.18342f
C25 VREFL F_A1 0.09381f
C26 XGAIN.XSTART.NODEP XGAIN.XBUF.INP 4.366f
C27 a_n17500_n24800# XFDAC.CTRL_B 0.20694f
C28 a_n41900_n28902# a_n38900_n28902# 0.24827f
C29 F_A1 VREFH 0.26088f
C30 XGAIN.XSTART.NODEN XGAIN.XBUF.INN 4.366f
C31 a_n38900_n28902# a_n35900_n28902# 0.24524f
C32 VDD XGAIN.XBUF.INP 0.76185f
C33 VREFL G_B1 0.09381f
C34 VREFL G_A4 0.09381f
C35 SEL_A SEL_B 0.01148f
C36 VREFL F_A4 0.08914f
C37 VDD XGAIN.XBUF.INN 0.20898f
C38 G_A4 VREFH 0.26088f
C39 G_B1 VREFH 0.26088f
C40 XGAIN.XSTART.NODEP XGDAC.CTRL_A 0.15638f
C41 XFAST.X2.INN XFAST.X2.INP 0.86002f
C42 XSEL.A_P XSEL.B_P 0.87611f
C43 VREFL F_A0 0.09381f
C44 F_A4 VREFH 0.26088f
C45 VREFL F_B2 0.09381f
C46 XGAIN.XSTART.NODEN XGDAC.CTRL_A 0.24114f
C47 G_A1 G_A1B 0.12533f
C48 F_A4B F_A4 0.12533f
C49 F_A0 VREFH 0.26088f
C50 F_B2 VREFH 0.26088f
C51 VREFL G_B2 0.09381f
C52 VREFL G_A3 0.09381f
C53 VDD CLK_P 0.46595f
C54 VDD XFAST.X2.INN 0.27616f
C55 VREFL F_A3 0.09381f
C56 XGAIN.XSTART.NODEN XGAIN.XSTART.NODEP 0.88357f
C57 VDD XSEL.B_N 0.30456f
C58 G_A3 VREFH 0.26088f
C59 G_B2 VREFH 0.26088f
C60 VDD XFAST.X2.INP 0.55085f
C61 XSEL.B_N XSEL.A_N 0.72385f
C62 XFAST.X2.INN XFDAC.CTRL_B 0.14401f
C63 VREFL F_B0 0.09381f
C64 XFAST.X2.INP XFAST.XBUF.INP 1.43936f
C65 F_A3 VREFH 0.26088f
C66 VREFL F_B3 0.09381f
C67 XGAIN.XSTART.NODEP VDD 0.48219f
C68 XGAIN.X2.INP XGAIN.X2.INN 0.86001f
C69 XGAIN.XSTART.NODEN VDD 0.20898f
C70 F_B0 VREFH 0.26088f
C71 F_B3 VREFH 0.26088f
C72 XFAST.XBUF.INN XFDAC.CTRL_A 1.05994f
C73 XGDAC.CTRL_B XGAIN.XBUF.INN 5.75172f
C74 VREFL G_B3 0.09381f
C75 a_32500_n24800# a_35500_n24800# 0.24524f
C76 VREFL F_A2 0.09381f
C77 VDD XFAST.XBUF.INP 0.83051f
C78 VDD XSEL.A_N 0.22915f
C79 XGAIN.XBUF.INP XSEL.B_P 0.18342f
C80 G_B3 VREFH 0.26088f
C81 VREFL F_B1 0.09381f
C82 F_A2 VREFH 0.26088f
C83 VREFL F_B4 0.09275f
C84 XGDAC.CTRL_B XGDAC.CTRL_A 10.8264f
C85 SEL_A XSEL.A_P 0.14201f
C86 F_A3B F_A3 0.12533f
C87 F_B1 VREFH 0.26088f
C88 F_B4 VREFH 0.26088f
C89 F_A0B F_A0 0.12533f
C90 F_A1B F_A1 0.12533f
C91 XGAIN.X2.INN XGAIN.XBUF.INN 1.43949f
C92 VREFL G_B4 0.08914f
C93 G_B4 VREFH 0.26088f
C94 XFAST.XSTART.NODEP XFAST.X2.INP 0.18713f
C95 XGAIN.XSTART.NODEN XGDAC.CTRL_B 4.53574f
C96 XSEL.B_P XSEL.B_N 3.35358f
C97 VREFL VREFH 0.34519f
C98 CLK_P CLK_N 0.17239f
C99 FAST_KICKP FAST_KICKN 0.13731f
C100 G_B1B G_B1 0.12533f
C101 XGAIN.X2.INN XGDAC.CTRL_A 0.13653f
C102 F_A4B VREFL 0.25739f
C103 XGAIN.XSTART.NODEP GAIN_KICKP 0.05732f
C104 XFAST.XSTART.NODEN XFAST.X2.INN 0.18713f
C105 VDD XFAST.XSTART.NODEP 0.55085f
C106 XFAST.XSTART.NODEP XFAST.XBUF.INP 4.36587f
C107 G_A4B G_A4 0.12533f
C108 G_A2 VREFL 0.09381f
C109 VDD XSEL.B_P 0.97953f
C110 XSEL.B_P XSEL.A_N 3.13793f
C111 FAST_KICKP XFAST.XSTART.NODEP 0.05732f
C112 XGAIN.XSTART.NODEN XGAIN.X2.INN 0.18726f
C113 VDD CLK_N 0.46247f
C114 G_A2 VREFH 0.26088f
C115 F_A3B VREFL 0.25739f
C116 F_A2B F_A2 0.12533f
C117 VDD XFAST.XSTART.NODEN 0.27616f
C118 G_A0B VREFL 0.25739f
C119 VDD XGAIN.X2.INN 0.20898f
C120 F_B0B F_B0 0.12533f
C121 XFAST.XSTART.NODEN XFDAC.CTRL_B 4.54367f
C122 G_B3B G_B3 0.12533f
C123 G_A1 VREFL 0.09381f
C124 G_A1 VREFH 0.26088f
C125 VREFL F_A0B 0.25739f
C126 G_B2B G_B2 0.12533f
C127 SEL_A XSEL.B_N 0.0184f
C128 F_A2B VREFL 0.25739f
C129 G_B0B VREFL 0.25739f
C130 F_B2B F_B2 0.12533f
C131 FAST_KICKN XFAST.XSTART.NODEN 0.05905f
C132 VREFL G_B3B 0.25739f
C133 G_A3B G_A3 0.12533f
C134 G_A0 VREFL 0.09381f
C135 a_38500_n24800# XGDAC.CTRL_B 0.20694f
C136 XFAST.X2.INN XFAST.XBUF.INN 1.43936f
C137 a_n41900_n28902# XFDAC.CTRL_A 0.20694f
C138 G_A0 VREFH 0.26088f
C139 XGAIN.X2.INN XGDAC.CTRL_B 0.13927f
C140 a_35500_n24800# a_38500_n24800# 0.24827f
C141 VREFL F_B0B 0.25739f
C142 F_A1B VREFL 0.25739f
C143 SEL_B XSEL.B_N 0.14942f
C144 XFAST.XSTART.NODEP XFAST.XSTART.NODEN 0.88358f
C145 a_14100_n28902# a_17100_n28902# 0.24827f
C146 G_B1B VREFL 0.25739f
C147 F_B1B F_B1 0.12533f
C148 G_B4B G_B4 0.12533f
C149 XFAST.X2.INN XFDAC.CTRL_A 0.31147f
C150 VREFL G_B4B 0.25739f
C151 G_B0 VREFL 0.09381f
C152 VREFL G_A4B 0.25739f
C153 XFAST.X2.INP XFDAC.CTRL_A 0.27417f
C154 XGAIN.XSTART.NODEN GAIN_KICKN 0.05905f
C155 VDD XFAST.XBUF.INN 0.27616f
C156 G_B0 VREFH 0.26088f
C157 XFAST.XBUF.INP XFAST.XBUF.INN 0.86002f
C158 SEL_B XSEL.A_N 0.14218f
C159 VREFL F_B1B 0.25739f
C160 XFAST.XBUF.INN XSEL.A_N 0.1833f
C161 a_n17500_n24800# a_n20500_n24800# 0.24827f
C162 G_B2B VREFL 0.25739f
C163 XFDAC.CTRL_B XFAST.XBUF.INN 5.77076f
C164 G_A0B G_A0 0.12533f
C165 a_n23500_n24800# a_n20500_n24800# 0.24524f
C166 F_B3B F_B3 0.12533f
C167 XFAST.XBUF.INP XFDAC.CTRL_A 0.54681f
C168 a_n23500_n24800# a_n27200_n29600# 0.20075f
C169 VREFL G_A3B 0.25739f
C170 XFDAC.CTRL_B XFDAC.CTRL_A 9.62888f
C171 XGAIN.X2.INP XGAIN.XBUF.INP 1.43949f
C172 VREFL F_B2B 0.25739f
C173 SEL_A XSEL.B_P 0.1486f
C174 a_20100_n28902# a_17100_n28902# 0.24524f
C175 VREFL G_A2B 0.25739f
C176 a_14100_n28902# XGDAC.CTRL_A 0.20694f
C177 G_B4B VSS 2.13457f
C178 G_B3B VSS 2.13453f
C179 G_B2B VSS 2.13453f
C180 G_B1B VSS 2.13453f
C181 G_B0B VSS 2.13453f
C182 G_A0B VSS 2.13453f
C183 G_A1B VSS 2.13453f
C184 G_A2B VSS 2.13453f
C185 G_A3B VSS 2.13453f
C186 G_A4B VSS 2.13457f
C187 G_B4 VSS 3.35924f
C188 G_B3 VSS 3.35416f
C189 G_B2 VSS 3.35416f
C190 G_B1 VSS 3.35416f
C191 G_B0 VSS 3.35416f
C192 G_A0 VSS 3.35416f
C193 G_A1 VSS 3.35416f
C194 G_A2 VSS 3.35416f
C195 G_A3 VSS 3.35416f
C196 G_A4 VSS 3.36508f
C197 F_B4B VSS 2.13457f
C198 F_B3B VSS 2.13453f
C199 F_B2B VSS 2.13453f
C200 F_B1B VSS 2.13453f
C201 F_B0B VSS 2.13453f
C202 F_A0B VSS 2.13453f
C203 F_A1B VSS 2.13453f
C204 F_A2B VSS 2.13453f
C205 F_A3B VSS 2.13453f
C206 F_A4B VSS 2.13457f
C207 VREFH VSS 33.61518f
C208 F_B4 VSS 3.35895f
C209 F_B3 VSS 3.35416f
C210 F_B2 VSS 3.35416f
C211 F_B1 VSS 3.35416f
C212 F_B0 VSS 3.35416f
C213 F_A0 VSS 3.35416f
C214 F_A1 VSS 3.35416f
C215 F_A2 VSS 3.35416f
C216 F_A3 VSS 3.35416f
C217 F_A4 VSS 3.36579f
C218 VREFL VSS 46.81561f
C219 GAIN_KICKN VSS 1.74963f
C220 GAIN_KICKP VSS 1.7158f
C221 FAST_KICKN VSS 1.74963f
C222 FAST_KICKP VSS 1.7158f
C223 SEL_B VSS 5.21771f
C224 SEL_A VSS 4.18664f
C225 SEL_BUF VSS 3.41177f
C226 CLK_N VSS 5.41142f
C227 CLK_P VSS 5.4923f
C228 VDD VSS 0.13872p
C229 a_38500_n24800# VSS 5.20362f
C230 a_35500_n24800# VSS 5.27319f
C231 a_28800_n29600# VSS 4.18334f
C232 a_32500_n24800# VSS 5.98141f
C233 a_23100_n28902# VSS 4.18334f
C234 a_20100_n28902# VSS 5.98141f
C235 a_17100_n28902# VSS 5.27319f
C236 a_14100_n28902# VSS 5.20362f
C237 a_n17500_n24800# VSS 5.20362f
C238 a_n20500_n24800# VSS 5.27319f
C239 a_n27200_n29600# VSS 4.18334f
C240 a_n23500_n24800# VSS 5.98141f
C241 a_n32900_n28902# VSS 4.18334f
C242 a_n35900_n28902# VSS 5.98141f
C243 a_n38900_n28902# VSS 5.27319f
C244 a_n41900_n28902# VSS 5.20362f
C245 XGAIN.XSTART.NODEN VSS 21.7925f
C246 XGAIN.XSTART.NODEP VSS 21.56697f
C247 XFAST.XSTART.NODEN VSS 21.83153f
C248 XFAST.XSTART.NODEP VSS 21.62777f
C249 XGAIN.X2.INN VSS 15.03916f
C250 XGAIN.X2.INP VSS 15.29174f
C251 XFAST.X2.INN VSS 15.08411f
C252 XFAST.X2.INP VSS 15.34884f
C253 XGAIN.XBUF.INN VSS 28.42047f
C254 XGAIN.XBUF.INP VSS 30.14346f
C255 XFAST.XBUF.INN VSS 28.26561f
C256 XFAST.XBUF.INP VSS 30.12382f
C257 XSEL.A_N VSS 24.62635f
C258 XSEL.B_N VSS 29.51592f
C259 XSEL.B_P VSS 30.01324f
C260 XSEL.A_P VSS 30.46792f
C261 a_n5996_53500.t0 VSS 0.13641f
C262 a_n5996_53500.n0 VSS 0.08288f
C263 a_n5996_53500.n1 VSS 0.08288f
C264 a_n5996_53500.n2 VSS 1.0083f
C265 a_n5996_53500.n3 VSS 2.13373f
C266 a_n5996_53500.t7 VSS 0.23065f
C267 a_n5996_53500.t8 VSS 0.23074f
C268 a_n5996_53500.n4 VSS 0.18172f
C269 a_n5996_53500.n5 VSS 0.28507f
C270 a_n5996_53500.t6 VSS 0.22941f
C271 a_n5996_53500.n6 VSS 0.08196f
C272 a_n5996_53500.t5 VSS 0.22941f
C273 a_n5996_53500.n7 VSS 0.08196f
C274 a_n5996_53500.n8 VSS 0.08223f
C275 a_n5996_53500.n9 VSS 0.24815f
C276 a_n5996_53500.n10 VSS 0.08223f
C277 a_n5996_53500.t1 VSS 0.22857f
C278 a_n5996_53500.t2 VSS 0.22848f
C279 a_n5996_53500.n11 VSS 0.18172f
C280 a_n5996_53500.n12 VSS 0.28507f
C281 a_n5996_53500.t3 VSS 0.22724f
C282 a_n5996_53500.n13 VSS 0.08196f
C283 a_n5996_53500.n14 VSS 0.08196f
C284 a_n5996_53500.t4 VSS 0.22724f
C285 a_n2796_53500.t8 VSS 0.14037f
C286 a_n2796_53500.n0 VSS 0.09015f
C287 a_n2796_53500.n1 VSS 0.09015f
C288 a_n2796_53500.n2 VSS 0.85875f
C289 a_n2796_53500.n3 VSS 2.09736f
C290 a_n2796_53500.t6 VSS 0.24973f
C291 a_n2796_53500.t7 VSS 0.24982f
C292 a_n2796_53500.n4 VSS 0.19766f
C293 a_n2796_53500.n5 VSS 0.31008f
C294 a_n2796_53500.t5 VSS 0.24838f
C295 a_n2796_53500.n6 VSS 0.08915f
C296 a_n2796_53500.t4 VSS 0.24839f
C297 a_n2796_53500.n7 VSS 0.08915f
C298 a_n2796_53500.n8 VSS 0.08944f
C299 a_n2796_53500.n9 VSS 0.33381f
C300 a_n2796_53500.n10 VSS 0.08944f
C301 a_n2796_53500.t0 VSS 0.24367f
C302 a_n2796_53500.t1 VSS 0.24358f
C303 a_n2796_53500.n11 VSS 0.19766f
C304 a_n2796_53500.n12 VSS 0.31008f
C305 a_n2796_53500.t2 VSS 0.24223f
C306 a_n2796_53500.n13 VSS 0.08915f
C307 a_n2796_53500.n14 VSS 0.08915f
C308 a_n2796_53500.t3 VSS 0.24223f
C309 XSEL.A_P.n0 VSS 0.03856f
C310 XSEL.A_P.n1 VSS 0.03856f
C311 XSEL.A_P.n2 VSS 0.16093f
C312 XSEL.A_P.n3 VSS 0.21058f
C313 XSEL.A_P.t2 VSS 0.14952f
C314 XSEL.A_P.t3 VSS 0.08396f
C315 XSEL.A_P.n4 VSS 1.19988f
C316 XSEL.A_P.n5 VSS 0.56064f
C317 XSEL.A_P.n6 VSS 0.05464f
C318 XSEL.A_P.t1 VSS 0.12894f
C319 XSEL.A_P.n7 VSS 0.04019f
C320 XSEL.A_P.t0 VSS 0.12894f
C321 XSEL.A_P.n8 VSS 0.04019f
C322 XSEL.A_P.n9 VSS 0.01639f
C323 XSEL.B_P.n0 VSS 0.04324f
C324 XSEL.B_P.n1 VSS 0.04324f
C325 XSEL.B_P.n2 VSS 0.18046f
C326 XSEL.B_P.n3 VSS 0.24255f
C327 XSEL.B_P.t0 VSS 0.14909f
C328 XSEL.B_P.t1 VSS 0.09287f
C329 XSEL.B_P.n4 VSS 1.31448f
C330 XSEL.B_P.n5 VSS 0.6287f
C331 XSEL.B_P.n6 VSS 0.06128f
C332 XSEL.B_P.t3 VSS 0.14186f
C333 XSEL.B_P.n7 VSS 0.04507f
C334 XSEL.B_P.t2 VSS 0.14186f
C335 XSEL.B_P.n8 VSS 0.04507f
C336 XSEL.B_P.n9 VSS 0.01838f
C337 XSEL.B_N.n0 VSS 0.17539f
C338 XSEL.B_N.n1 VSS 0.03127f
C339 XSEL.B_N.n2 VSS 0.03127f
C340 XSEL.B_N.n3 VSS 0.13049f
C341 XSEL.B_N.n4 VSS 2.60984f
C342 XSEL.B_N.t2 VSS 0.11784f
C343 XSEL.B_N.n5 VSS 0.03259f
C344 XSEL.B_N.t1 VSS 0.11784f
C345 XSEL.B_N.n6 VSS 0.03259f
C346 XSEL.B_N.n7 VSS 0.02769f
C347 XSEL.B_N.t0 VSS 0.11235f
C348 XSEL.B_N.t3 VSS 0.20438f
C349 XSEL.B_N.n8 VSS 1.09347f
C350 XSEL.A_N.n0 VSS 0.24325f
C351 XSEL.A_N.n1 VSS 0.04454f
C352 XSEL.A_N.n2 VSS 0.04454f
C353 XSEL.A_N.n3 VSS 0.18589f
C354 XSEL.A_N.n4 VSS 3.44521f
C355 XSEL.A_N.t2 VSS 0.15611f
C356 XSEL.A_N.n5 VSS 0.04643f
C357 XSEL.A_N.t1 VSS 0.15611f
C358 XSEL.A_N.n6 VSS 0.04643f
C359 XSEL.A_N.n7 VSS 0.03945f
C360 XSEL.A_N.t0 VSS 0.14581f
C361 XSEL.A_N.t3 VSS 0.30165f
C362 XSEL.A_N.n8 VSS 1.5805f
C363 a_n5852_53500.t8 VSS 0.08283f
C364 a_n5852_53500.t7 VSS 0.08283f
C365 a_n5852_53500.n0 VSS 0.26015f
C366 a_n5852_53500.n1 VSS 0.15107f
C367 a_n5852_53500.t10 VSS 0.08947f
C368 a_n5852_53500.t5 VSS 0.08947f
C369 a_n5852_53500.n2 VSS 0.38418f
C370 a_n5852_53500.t1 VSS 0.08947f
C371 a_n5852_53500.t0 VSS 0.08947f
C372 a_n5852_53500.n3 VSS 0.3804f
C373 a_n5852_53500.n4 VSS 1.17769f
C374 a_n5852_53500.t3 VSS 0.08669f
C375 a_n5852_53500.t2 VSS 0.0867f
C376 a_n5852_53500.n5 VSS 0.38418f
C377 a_n5852_53500.t4 VSS 0.0867f
C378 a_n5852_53500.t11 VSS 0.08669f
C379 a_n5852_53500.n6 VSS 0.3804f
C380 a_n5852_53500.n7 VSS 1.17769f
C381 a_n5852_53500.n8 VSS 1.81005f
C382 a_n5852_53500.t6 VSS 0.35421f
C383 a_n5852_53500.n9 VSS 0.13683f
C384 a_n5852_53500.n10 VSS 0.36058f
C385 a_n5852_53500.n11 VSS 0.13468f
C386 a_n5852_53500.t9 VSS 0.35636f
C387 a_n4252_53500.t3 VSS 0.08488f
C388 a_n4252_53500.t5 VSS 0.08487f
C389 a_n4252_53500.n0 VSS 0.3664f
C390 a_n4252_53500.t11 VSS 0.08487f
C391 a_n4252_53500.t4 VSS 0.08488f
C392 a_n4252_53500.n1 VSS 0.35603f
C393 a_n4252_53500.t0 VSS 0.09042f
C394 a_n4252_53500.t2 VSS 0.09043f
C395 a_n4252_53500.n2 VSS 0.3664f
C396 a_n4252_53500.t6 VSS 0.09043f
C397 a_n4252_53500.t1 VSS 0.09042f
C398 a_n4252_53500.n3 VSS 0.35603f
C399 a_n4252_53500.n4 VSS 0.84628f
C400 a_n4252_53500.n5 VSS 2.41446f
C401 a_n4252_53500.n6 VSS 0.66754f
C402 a_n4252_53500.t9 VSS 0.08058f
C403 a_n4252_53500.t8 VSS 0.08058f
C404 a_n4252_53500.n7 VSS 0.26603f
C405 a_n4252_53500.t7 VSS 0.36014f
C406 a_n4252_53500.n8 VSS 0.15483f
C407 a_n4252_53500.n9 VSS 0.15449f
C408 a_n4252_53500.n10 VSS 0.136f
C409 a_n4252_53500.t10 VSS 0.35796f
C410 a_1748_53500.t4 VSS 0.13915f
C411 a_1748_53500.t3 VSS 0.13915f
C412 a_1748_53500.n0 VSS 0.41902f
C413 a_1748_53500.n1 VSS 0.13651f
C414 a_1748_53500.t2 VSS 0.59065f
C415 a_1748_53500.n2 VSS 0.12213f
C416 a_1748_53500.t8 VSS 0.0988f
C417 a_1748_53500.t9 VSS 0.09879f
C418 a_1748_53500.n3 VSS 0.25721f
C419 a_1748_53500.t0 VSS 0.09879f
C420 a_1748_53500.t1 VSS 0.0988f
C421 a_1748_53500.n4 VSS 0.24616f
C422 a_1748_53500.n5 VSS 0.55535f
C423 a_1748_53500.t6 VSS 0.09542f
C424 a_1748_53500.t11 VSS 0.09543f
C425 a_1748_53500.n6 VSS 0.25721f
C426 a_1748_53500.t7 VSS 0.09543f
C427 a_1748_53500.t10 VSS 0.09542f
C428 a_1748_53500.n7 VSS 0.24616f
C429 a_1748_53500.n8 VSS 0.55535f
C430 a_1748_53500.n9 VSS 0.39669f
C431 a_1748_53500.n10 VSS 0.59694f
C432 a_1748_53500.n11 VSS 0.12036f
C433 a_1748_53500.t5 VSS 0.59242f
C434 XFAST.XBUF.INP.n0 VSS 0.11704f
C435 XFAST.XBUF.INP.n1 VSS 0.11704f
C436 XFAST.XBUF.INP.n2 VSS 3.82357f
C437 XFAST.XBUF.INP.n3 VSS 0.28291f
C438 XFAST.XBUF.INP.t3 VSS 0.18034f
C439 XFAST.XBUF.INP.t0 VSS 0.09263f
C440 XFAST.XBUF.INP.n4 VSS 1.3238f
C441 XFAST.XBUF.INP.n5 VSS 0.61855f
C442 XFAST.XBUF.INP.n6 VSS 0.06029f
C443 XFAST.XBUF.INP.t2 VSS 0.14051f
C444 XFAST.XBUF.INP.n7 VSS 0.04434f
C445 XFAST.XBUF.INP.t1 VSS 0.14051f
C446 XFAST.XBUF.INP.n8 VSS 0.04434f
C447 XFAST.XBUF.INP.n9 VSS 0.01809f
C448 a_n31052_37900.n0 VSS 0.05098f
C449 a_n31052_37900.t4 VSS 0.10859f
C450 a_n31052_37900.t3 VSS 0.10859f
C451 a_n31052_37900.n1 VSS 0.50607f
C452 a_n31052_37900.t2 VSS 0.6462f
C453 a_n31052_37900.n2 VSS 0.09288f
C454 a_n31052_37900.n3 VSS 0.06772f
C455 a_n31052_37900.t7 VSS 0.06613f
C456 a_n31052_37900.t6 VSS 0.06613f
C457 a_n31052_37900.n4 VSS 0.25163f
C458 a_n31052_37900.t1 VSS 0.05591f
C459 a_n31052_37900.t0 VSS 0.05591f
C460 a_n31052_37900.n5 VSS 0.22084f
C461 a_n31052_37900.n6 VSS 1.78065f
C462 a_n31052_37900.n7 VSS 0.04981f
C463 a_n31052_37900.n8 VSS 0.254f
C464 a_n31052_37900.n9 VSS 0.05086f
C465 a_n31052_37900.n10 VSS 0.04994f
C466 a_n31052_37900.n11 VSS 0.06772f
C467 a_n31052_37900.n12 VSS 0.10043f
C468 a_n31052_37900.n13 VSS 0.09288f
C469 a_n31052_37900.t5 VSS 0.6462f
C470 XFAST.XBUF.INN.n0 VSS 0.17771f
C471 XFAST.XBUF.INN.n1 VSS 0.17771f
C472 XFAST.XBUF.INN.n2 VSS 5.80559f
C473 XFAST.XBUF.INN.n3 VSS 0.46554f
C474 XFAST.XBUF.INN.t3 VSS 0.20339f
C475 XFAST.XBUF.INN.n4 VSS 0.06797f
C476 XFAST.XBUF.INN.t2 VSS 0.20339f
C477 XFAST.XBUF.INN.n5 VSS 0.06733f
C478 XFAST.XBUF.INN.n6 VSS 0.05721f
C479 XFAST.XBUF.INN.t1 VSS 0.20318f
C480 XFAST.XBUF.INN.t0 VSS 0.43746f
C481 XFAST.XBUF.INN.n7 VSS 2.29208f
C482 a_n28972_38000.t1 VSS 0.25282f
C483 a_n28972_38000.t0 VSS 0.26877f
C484 a_n28972_38000.t3 VSS 0.22652f
C485 a_n28972_38000.n0 VSS 1.11704f
C486 a_n28972_38000.n1 VSS 0.30058f
C487 a_n28972_38000.t2 VSS 0.25282f
C488 XGAIN.XBUF.INP.n0 VSS 0.11502f
C489 XGAIN.XBUF.INP.n1 VSS 0.11502f
C490 XGAIN.XBUF.INP.n2 VSS 3.75744f
C491 XGAIN.XBUF.INP.n3 VSS 0.28421f
C492 XGAIN.XBUF.INP.t1 VSS 0.1769f
C493 XGAIN.XBUF.INP.t0 VSS 0.08979f
C494 XGAIN.XBUF.INP.n4 VSS 1.27088f
C495 XGAIN.XBUF.INP.n5 VSS 0.60785f
C496 XGAIN.XBUF.INP.n6 VSS 0.05925f
C497 XGAIN.XBUF.INP.t3 VSS 0.13804f
C498 XGAIN.XBUF.INP.n7 VSS 0.04358f
C499 XGAIN.XBUF.INP.t2 VSS 0.13804f
C500 XGAIN.XBUF.INP.n8 VSS 0.04358f
C501 XGAIN.XBUF.INP.n9 VSS 0.01777f
C502 a_24948_37900.n0 VSS 0.05586f
C503 a_24948_37900.t4 VSS 0.07932f
C504 a_24948_37900.t3 VSS 0.07932f
C505 a_24948_37900.n1 VSS 0.36734f
C506 a_24948_37900.t2 VSS 0.46554f
C507 a_24948_37900.n2 VSS 0.0895f
C508 a_24948_37900.n3 VSS 0.07419f
C509 a_24948_37900.t6 VSS 0.06892f
C510 a_24948_37900.t7 VSS 0.06892f
C511 a_24948_37900.n4 VSS 0.2757f
C512 a_24948_37900.t0 VSS 0.05903f
C513 a_24948_37900.t1 VSS 0.05903f
C514 a_24948_37900.n5 VSS 0.24196f
C515 a_24948_37900.n6 VSS 2.00892f
C516 a_24948_37900.n7 VSS 0.05458f
C517 a_24948_37900.n8 VSS 0.33626f
C518 a_24948_37900.n9 VSS 0.05572f
C519 a_24948_37900.n10 VSS 0.05472f
C520 a_24948_37900.n11 VSS 0.07419f
C521 a_24948_37900.n12 VSS 0.09735f
C522 a_24948_37900.n13 VSS 0.0895f
C523 a_24948_37900.t5 VSS 0.46554f
C524 XGAIN.XBUF.INN.n0 VSS 0.17375f
C525 XGAIN.XBUF.INN.n1 VSS 0.17375f
C526 XGAIN.XBUF.INN.n2 VSS 5.67609f
C527 XGAIN.XBUF.INN.n3 VSS 0.46451f
C528 XGAIN.XBUF.INN.t3 VSS 0.19872f
C529 XGAIN.XBUF.INN.n4 VSS 0.06645f
C530 XGAIN.XBUF.INN.t2 VSS 0.19872f
C531 XGAIN.XBUF.INN.n5 VSS 0.06583f
C532 XGAIN.XBUF.INN.n6 VSS 0.05594f
C533 XGAIN.XBUF.INN.t1 VSS 0.19878f
C534 XGAIN.XBUF.INN.t0 VSS 0.41282f
C535 XGAIN.XBUF.INN.n7 VSS 2.20861f
C536 a_27028_38000.t3 VSS 0.16978f
C537 a_27028_38000.t0 VSS 0.26879f
C538 a_27028_38000.t1 VSS 0.24136f
C539 a_27028_38000.n0 VSS 1.21648f
C540 a_27028_38000.n1 VSS 0.32499f
C541 a_27028_38000.t2 VSS 0.16978f
C542 XFAST.X2.INP.n0 VSS 0.11873f
C543 XFAST.X2.INP.n1 VSS 1.08454f
C544 XFAST.X2.INP.t3 VSS 0.16156f
C545 XFAST.X2.INP.t0 VSS 0.09397f
C546 XFAST.X2.INP.n2 VSS 1.34293f
C547 XFAST.X2.INP.n3 VSS 0.62748f
C548 XFAST.X2.INP.n4 VSS 0.06116f
C549 XFAST.X2.INP.t2 VSS 0.14409f
C550 XFAST.X2.INP.n5 VSS 0.04498f
C551 XFAST.X2.INP.t1 VSS 0.14409f
C552 XFAST.X2.INP.n6 VSS 0.04498f
C553 XFAST.X2.INP.n7 VSS 0.01835f
C554 a_n31052_25100.n0 VSS 0.05144f
C555 a_n31052_25100.t4 VSS 0.10956f
C556 a_n31052_25100.t3 VSS 0.10956f
C557 a_n31052_25100.n1 VSS 0.51061f
C558 a_n31052_25100.t2 VSS 0.652f
C559 a_n31052_25100.n2 VSS 0.09371f
C560 a_n31052_25100.n3 VSS 0.06832f
C561 a_n31052_25100.t7 VSS 0.05692f
C562 a_n31052_25100.t6 VSS 0.05692f
C563 a_n31052_25100.n4 VSS 0.25389f
C564 a_n31052_25100.t0 VSS 0.05652f
C565 a_n31052_25100.t1 VSS 0.05652f
C566 a_n31052_25100.n5 VSS 0.22282f
C567 a_n31052_25100.n6 VSS 1.79664f
C568 a_n31052_25100.n7 VSS 0.05026f
C569 a_n31052_25100.n8 VSS 0.25628f
C570 a_n31052_25100.n9 VSS 0.05131f
C571 a_n31052_25100.n10 VSS 0.05039f
C572 a_n31052_25100.n11 VSS 0.06832f
C573 a_n31052_25100.n12 VSS 0.10133f
C574 a_n31052_25100.n13 VSS 0.09371f
C575 a_n31052_25100.t5 VSS 0.652f
C576 XFAST.X2.INN.n0 VSS 0.12113f
C577 XFAST.X2.INN.n1 VSS 1.13097f
C578 XFAST.X2.INN.t2 VSS 0.15792f
C579 XFAST.X2.INN.n2 VSS 0.04633f
C580 XFAST.X2.INN.t1 VSS 0.15792f
C581 XFAST.X2.INN.n3 VSS 0.04589f
C582 XFAST.X2.INN.n4 VSS 0.039f
C583 XFAST.X2.INN.t3 VSS 0.14724f
C584 XFAST.X2.INN.t0 VSS 0.29818f
C585 XFAST.X2.INN.n5 VSS 1.56232f
C586 a_n28972_25200.t1 VSS 0.25282f
C587 a_n28972_25200.t0 VSS 0.28871f
C588 a_n28972_25200.t3 VSS 0.22898f
C589 a_n28972_25200.n0 VSS 1.11704f
C590 a_n28972_25200.n1 VSS 0.30058f
C591 a_n28972_25200.t2 VSS 14.25412f
C592 XGAIN.X2.INP.n0 VSS 0.11646f
C593 XGAIN.X2.INP.n1 VSS 1.07009f
C594 XGAIN.X2.INP.t3 VSS 0.15805f
C595 XGAIN.X2.INP.t2 VSS 0.09092f
C596 XGAIN.X2.INP.n2 VSS 1.28688f
C597 XGAIN.X2.INP.n3 VSS 0.6155f
C598 XGAIN.X2.INP.n4 VSS 0.05999f
C599 XGAIN.X2.INP.t1 VSS 0.14149f
C600 XGAIN.X2.INP.n5 VSS 0.04412f
C601 XGAIN.X2.INP.t0 VSS 0.14149f
C602 XGAIN.X2.INP.n6 VSS 0.04412f
C603 XGAIN.X2.INP.n7 VSS 0.018f
C604 a_24948_25100.n0 VSS 0.05638f
C605 a_24948_25100.t4 VSS 25.5359f
C606 a_24948_25100.t3 VSS 0.08005f
C607 a_24948_25100.n1 VSS 0.37074f
C608 a_24948_25100.t2 VSS 0.46985f
C609 a_24948_25100.n2 VSS 0.09033f
C610 a_24948_25100.n3 VSS 0.07488f
C611 a_24948_25100.t6 VSS 0.05984f
C612 a_24948_25100.t7 VSS 0.05984f
C613 a_24948_25100.n4 VSS 0.27826f
C614 a_24948_25100.t0 VSS 0.05964f
C615 a_24948_25100.t1 VSS 0.05964f
C616 a_24948_25100.n5 VSS 0.2442f
C617 a_24948_25100.n6 VSS 2.02754f
C618 a_24948_25100.n7 VSS 0.05509f
C619 a_24948_25100.n8 VSS 0.33937f
C620 a_24948_25100.n9 VSS 0.05624f
C621 a_24948_25100.n10 VSS 0.05522f
C622 a_24948_25100.n11 VSS 0.07488f
C623 a_24948_25100.n12 VSS 0.09825f
C624 a_24948_25100.n13 VSS 0.09033f
C625 a_24948_25100.t5 VSS 0.46985f
C626 XGAIN.X2.INN.n0 VSS 0.11765f
C627 XGAIN.X2.INN.n1 VSS 1.10485f
C628 XGAIN.X2.INN.t2 VSS 0.15402f
C629 XGAIN.X2.INN.n2 VSS 0.045f
C630 XGAIN.X2.INN.t1 VSS 0.15402f
C631 XGAIN.X2.INN.n3 VSS 0.04458f
C632 XGAIN.X2.INN.n4 VSS 0.03788f
C633 XGAIN.X2.INN.t0 VSS 0.14327f
C634 XGAIN.X2.INN.t3 VSS 0.27954f
C635 XGAIN.X2.INN.n5 VSS 1.49559f
C636 a_27028_25200.t3 VSS 0.16978f
C637 a_27028_25200.t1 VSS 0.30051f
C638 a_27028_25200.t0 VSS 0.24047f
C639 a_27028_25200.n0 VSS 1.21648f
C640 a_27028_25200.n1 VSS 0.32499f
C641 a_27028_25200.t2 VSS 0.16978f
C642 XFAST.XSTART.NODEP.t4 VSS 0.06939f
C643 XFAST.XSTART.NODEP.n0 VSS 0.12964f
C644 XFAST.XSTART.NODEP.n1 VSS 2.16655f
C645 XFAST.XSTART.NODEP.n2 VSS 0.31337f
C646 XFAST.XSTART.NODEP.t1 VSS 0.19983f
C647 XFAST.XSTART.NODEP.t0 VSS 0.1026f
C648 XFAST.XSTART.NODEP.n3 VSS 1.4663f
C649 XFAST.XSTART.NODEP.n4 VSS 0.68513f
C650 XFAST.XSTART.NODEP.n5 VSS 0.06678f
C651 XFAST.XSTART.NODEP.t2 VSS 0.1532f
C652 XFAST.XSTART.NODEP.n6 VSS 0.04912f
C653 XFAST.XSTART.NODEP.t3 VSS 0.1532f
C654 XFAST.XSTART.NODEP.n7 VSS 0.04912f
C655 XFAST.XSTART.NODEP.n8 VSS 0.02003f
C656 a_n31052_12300.t5 VSS 0.10956f
C657 a_n31052_12300.t7 VSS 26.1993f
C658 a_n31052_12300.n0 VSS 0.09371f
C659 a_n31052_12300.n1 VSS 0.06832f
C660 a_n31052_12300.n2 VSS 0.06832f
C661 a_n31052_12300.t0 VSS 0.06971f
C662 a_n31052_12300.t1 VSS 0.06971f
C663 a_n31052_12300.n3 VSS 0.25389f
C664 a_n31052_12300.t3 VSS 0.05836f
C665 a_n31052_12300.t2 VSS 0.05836f
C666 a_n31052_12300.n4 VSS 0.22282f
C667 a_n31052_12300.n5 VSS 1.79664f
C668 a_n31052_12300.n6 VSS 0.05144f
C669 a_n31052_12300.n7 VSS 0.05026f
C670 a_n31052_12300.n8 VSS 0.25628f
C671 a_n31052_12300.n9 VSS 0.05131f
C672 a_n31052_12300.n10 VSS 0.05039f
C673 a_n31052_12300.t4 VSS 0.652f
C674 a_n31052_12300.n11 VSS 0.09371f
C675 a_n31052_12300.n12 VSS 0.10133f
C676 a_n31052_12300.n13 VSS 0.51061f
C677 a_n31052_12300.t6 VSS 0.10956f
C678 XFAST.XSTART.NODEN.t3 VSS 0.0997f
C679 XFAST.XSTART.NODEN.n0 VSS 0.19707f
C680 XFAST.XSTART.NODEN.n1 VSS 3.31507f
C681 XFAST.XSTART.NODEN.n2 VSS 0.51624f
C682 XFAST.XSTART.NODEN.t1 VSS 0.23284f
C683 XFAST.XSTART.NODEN.n3 VSS 0.07537f
C684 XFAST.XSTART.NODEN.t0 VSS 0.23284f
C685 XFAST.XSTART.NODEN.n4 VSS 0.07466f
C686 XFAST.XSTART.NODEN.n5 VSS 0.06344f
C687 XFAST.XSTART.NODEN.t2 VSS 0.22528f
C688 XFAST.XSTART.NODEN.t4 VSS 0.48511f
C689 XFAST.XSTART.NODEN.n6 VSS 2.54172f
C690 a_n28972_12400.t1 VSS 0.25282f
C691 a_n28972_12400.t0 VSS 0.26826f
C692 a_n28972_12400.t3 VSS 0.22936f
C693 a_n28972_12400.n0 VSS 1.11704f
C694 a_n28972_12400.n1 VSS 0.30058f
C695 a_n28972_12400.t2 VSS 0.25282f
C696 XGAIN.XSTART.NODEP.t0 VSS 0.06867f
C697 XGAIN.XSTART.NODEP.n0 VSS 0.12809f
C698 XGAIN.XSTART.NODEP.n1 VSS 2.14068f
C699 XGAIN.XSTART.NODEP.n2 VSS 0.31652f
C700 XGAIN.XSTART.NODEP.t3 VSS 0.19762f
C701 XGAIN.XSTART.NODEP.t4 VSS 0.09999f
C702 XGAIN.XSTART.NODEP.n3 VSS 1.41536f
C703 XGAIN.XSTART.NODEP.n4 VSS 0.67695f
C704 XGAIN.XSTART.NODEP.n5 VSS 0.06598f
C705 XGAIN.XSTART.NODEP.t1 VSS 0.15126f
C706 XGAIN.XSTART.NODEP.n6 VSS 0.04853f
C707 XGAIN.XSTART.NODEP.t2 VSS 0.15126f
C708 XGAIN.XSTART.NODEP.n7 VSS 0.04853f
C709 XGAIN.XSTART.NODEP.n8 VSS 0.01979f
C710 a_24948_12300.n0 VSS 0.05638f
C711 a_24948_12300.t5 VSS 0.08005f
C712 a_24948_12300.t4 VSS 0.08005f
C713 a_24948_12300.n1 VSS 0.37074f
C714 a_24948_12300.t3 VSS 0.46985f
C715 a_24948_12300.n2 VSS 0.09033f
C716 a_24948_12300.n3 VSS 0.07488f
C717 a_24948_12300.t1 VSS 0.0729f
C718 a_24948_12300.t0 VSS 0.0729f
C719 a_24948_12300.n4 VSS 0.27826f
C720 a_24948_12300.t2 VSS 0.0616f
C721 a_24948_12300.t7 VSS 0.0616f
C722 a_24948_12300.n5 VSS 0.2442f
C723 a_24948_12300.n6 VSS 2.02754f
C724 a_24948_12300.n7 VSS 0.05509f
C725 a_24948_12300.n8 VSS 0.33937f
C726 a_24948_12300.n9 VSS 0.05624f
C727 a_24948_12300.n10 VSS 0.05522f
C728 a_24948_12300.n11 VSS 0.07488f
C729 a_24948_12300.n12 VSS 0.09825f
C730 a_24948_12300.n13 VSS 0.09033f
C731 a_24948_12300.t6 VSS 0.46985f
C732 XGAIN.XSTART.NODEN.t4 VSS 0.09883f
C733 XGAIN.XSTART.NODEN.n0 VSS 0.19519f
C734 XGAIN.XSTART.NODEN.n1 VSS 3.28353f
C735 XGAIN.XSTART.NODEN.n2 VSS 0.52184f
C736 XGAIN.XSTART.NODEN.t0 VSS 0.23025f
C737 XGAIN.XSTART.NODEN.n3 VSS 0.07465f
C738 XGAIN.XSTART.NODEN.t1 VSS 0.23025f
C739 XGAIN.XSTART.NODEN.n4 VSS 0.07395f
C740 XGAIN.XSTART.NODEN.n5 VSS 0.06284f
C741 XGAIN.XSTART.NODEN.t2 VSS 0.22307f
C742 XGAIN.XSTART.NODEN.t3 VSS 0.46377f
C743 XGAIN.XSTART.NODEN.n6 VSS 2.48119f
C744 a_27028_12400.t3 VSS 13.89058f
C745 a_27028_12400.t0 VSS 0.28023f
C746 a_27028_12400.t1 VSS 0.2408f
C747 a_27028_12400.n0 VSS 1.21648f
C748 a_27028_12400.n1 VSS 0.32499f
C749 a_27028_12400.t2 VSS 0.16978f
C750 a_n31052_n500.t5 VSS 0.10956f
C751 a_n31052_n500.t7 VSS 0.652f
C752 a_n31052_n500.n0 VSS 0.09371f
C753 a_n31052_n500.n1 VSS 0.06832f
C754 a_n31052_n500.n2 VSS 0.06832f
C755 a_n31052_n500.t1 VSS 0.06645f
C756 a_n31052_n500.t0 VSS 0.06645f
C757 a_n31052_n500.n3 VSS 0.25389f
C758 a_n31052_n500.t2 VSS 0.05623f
C759 a_n31052_n500.t3 VSS 0.05623f
C760 a_n31052_n500.n4 VSS 0.22282f
C761 a_n31052_n500.n5 VSS 1.79664f
C762 a_n31052_n500.n6 VSS 0.05144f
C763 a_n31052_n500.n7 VSS 0.05026f
C764 a_n31052_n500.n8 VSS 0.25628f
C765 a_n31052_n500.n9 VSS 0.05131f
C766 a_n31052_n500.n10 VSS 0.05039f
C767 a_n31052_n500.t4 VSS 0.652f
C768 a_n31052_n500.n11 VSS 0.09371f
C769 a_n31052_n500.n12 VSS 0.10133f
C770 a_n31052_n500.n13 VSS 0.51061f
C771 a_n31052_n500.t6 VSS 0.10956f
C772 a_n28972_n400.t1 VSS 0.25282f
C773 a_n28972_n400.t3 VSS 0.29571f
C774 a_n28972_n400.t0 VSS 0.23181f
C775 a_n28972_n400.n0 VSS 1.11704f
C776 a_n28972_n400.n1 VSS 0.30058f
C777 a_n28972_n400.t2 VSS 0.25282f
C778 a_24948_n500.n0 VSS 0.05638f
C779 a_24948_n500.t5 VSS 0.08005f
C780 a_24948_n500.t4 VSS 0.08005f
C781 a_24948_n500.n1 VSS 0.37074f
C782 a_24948_n500.t3 VSS 0.46985f
C783 a_24948_n500.n2 VSS 0.09033f
C784 a_24948_n500.n3 VSS 0.07488f
C785 a_24948_n500.t0 VSS 0.06929f
C786 a_24948_n500.t7 VSS 0.06929f
C787 a_24948_n500.n4 VSS 0.27826f
C788 a_24948_n500.t1 VSS 0.0594f
C789 a_24948_n500.t2 VSS 0.0594f
C790 a_24948_n500.n5 VSS 0.2442f
C791 a_24948_n500.n6 VSS 2.02754f
C792 a_24948_n500.n7 VSS 0.05509f
C793 a_24948_n500.n8 VSS 0.33937f
C794 a_24948_n500.n9 VSS 0.05624f
C795 a_24948_n500.n10 VSS 0.05522f
C796 a_24948_n500.n11 VSS 0.07488f
C797 a_24948_n500.n12 VSS 0.09825f
C798 a_24948_n500.n13 VSS 0.09033f
C799 a_24948_n500.t6 VSS 0.46985f
C800 a_27028_n400.t1 VSS 0.16978f
C801 a_27028_n400.t0 VSS 0.30826f
C802 a_27028_n400.t3 VSS 0.24341f
C803 a_27028_n400.n0 VSS 1.21648f
C804 a_27028_n400.n1 VSS 0.32499f
C805 a_27028_n400.t2 VSS 0.16978f
C806 a_n43400_n37702.t0 VSS 0.4057f
C807 a_n43400_n37702.t2 VSS 0.23035f
C808 a_n43400_n37702.t4 VSS 0.41127f
C809 a_n43400_n37702.t3 VSS 0.41127f
C810 a_n43400_n37702.n0 VSS 0.27469f
C811 a_n43400_n37702.n1 VSS 1.96457f
C812 a_n43400_n37702.n2 VSS 0.38558f
C813 a_n43400_n37702.t1 VSS 0.40569f
C814 a_n40400_n37702.t0 VSS 0.40602f
C815 a_n40400_n37702.t2 VSS 0.23054f
C816 a_n40400_n37702.t4 VSS 0.41173f
C817 a_n40400_n37702.t3 VSS 0.41173f
C818 a_n40400_n37702.n0 VSS 0.27493f
C819 a_n40400_n37702.n1 VSS 1.96623f
C820 a_n40400_n37702.n2 VSS 0.38591f
C821 a_n40400_n37702.t1 VSS 0.40601f
C822 a_n37400_n37702.t1 VSS 0.41173f
C823 a_n37400_n37702.t0 VSS 0.23054f
C824 a_n37400_n37702.t4 VSS 0.40601f
C825 a_n37400_n37702.t3 VSS 0.40602f
C826 a_n37400_n37702.n0 VSS 0.38591f
C827 a_n37400_n37702.n1 VSS 1.96623f
C828 a_n37400_n37702.n2 VSS 0.27493f
C829 a_n37400_n37702.t2 VSS 0.41173f
C830 a_n34400_n37702.t1 VSS 0.41173f
C831 a_n34400_n37702.t0 VSS 0.23054f
C832 a_n34400_n37702.t4 VSS 0.40601f
C833 a_n34400_n37702.t3 VSS 0.40602f
C834 a_n34400_n37702.n0 VSS 0.38591f
C835 a_n34400_n37702.n1 VSS 1.96623f
C836 a_n34400_n37702.n2 VSS 0.27493f
C837 a_n34400_n37702.t2 VSS 0.41173f
C838 a_n31400_n37702.t1 VSS 0.40602f
C839 a_n31400_n37702.t0 VSS 0.23054f
C840 a_n31400_n37702.t4 VSS 0.41173f
C841 a_n31400_n37702.t3 VSS 0.41173f
C842 a_n31400_n37702.n0 VSS 0.27493f
C843 a_n31400_n37702.n1 VSS 1.96623f
C844 a_n31400_n37702.n2 VSS 0.38591f
C845 a_n31400_n37702.t2 VSS 0.40601f
C846 a_n25000_n37702.t1 VSS 0.41173f
C847 a_n25000_n37702.t0 VSS 0.23054f
C848 a_n25000_n37702.t4 VSS 0.40602f
C849 a_n25000_n37702.t3 VSS 0.40601f
C850 a_n25000_n37702.n0 VSS 0.38591f
C851 a_n25000_n37702.n1 VSS 1.96623f
C852 a_n25000_n37702.n2 VSS 0.27493f
C853 a_n25000_n37702.t2 VSS 0.41173f
C854 a_n22000_n37702.t0 VSS 0.41173f
C855 a_n22000_n37702.t4 VSS 0.23054f
C856 a_n22000_n37702.t3 VSS 0.40602f
C857 a_n22000_n37702.t2 VSS 0.40601f
C858 a_n22000_n37702.n0 VSS 0.38591f
C859 a_n22000_n37702.n1 VSS 1.96623f
C860 a_n22000_n37702.n2 VSS 0.27493f
C861 a_n22000_n37702.t1 VSS 0.41173f
C862 a_n19000_n37702.t0 VSS 0.40601f
C863 a_n19000_n37702.t4 VSS 0.23054f
C864 a_n19000_n37702.t3 VSS 0.41173f
C865 a_n19000_n37702.t2 VSS 0.41173f
C866 a_n19000_n37702.n0 VSS 0.27493f
C867 a_n19000_n37702.n1 VSS 1.96623f
C868 a_n19000_n37702.n2 VSS 0.38591f
C869 a_n19000_n37702.t1 VSS 0.40602f
C870 a_n16000_n37702.t1 VSS 0.41173f
C871 a_n16000_n37702.t0 VSS 0.23054f
C872 a_n16000_n37702.t4 VSS 0.40602f
C873 a_n16000_n37702.t3 VSS 0.40601f
C874 a_n16000_n37702.n0 VSS 0.38591f
C875 a_n16000_n37702.n1 VSS 1.96623f
C876 a_n16000_n37702.n2 VSS 0.27493f
C877 a_n16000_n37702.t2 VSS 0.41173f
C878 a_n13000_n37702.t1 VSS 0.41166f
C879 a_n13000_n37702.t0 VSS 0.23052f
C880 a_n13000_n37702.t4 VSS 0.40598f
C881 a_n13000_n37702.t3 VSS 0.40597f
C882 a_n13000_n37702.n0 VSS 0.38586f
C883 a_n13000_n37702.n1 VSS 1.96602f
C884 a_n13000_n37702.n2 VSS 0.2749f
C885 a_n13000_n37702.t2 VSS 0.41165f
C886 a_12600_n37702.t0 VSS 0.40598f
C887 a_12600_n37702.t4 VSS 0.23052f
C888 a_12600_n37702.t3 VSS 0.41169f
C889 a_12600_n37702.t2 VSS 0.41169f
C890 a_12600_n37702.n0 VSS 0.2749f
C891 a_12600_n37702.n1 VSS 1.96602f
C892 a_12600_n37702.n2 VSS 0.38586f
C893 a_12600_n37702.t1 VSS 0.40597f
C894 a_15600_n37702.t0 VSS 0.41173f
C895 a_15600_n37702.t2 VSS 0.23054f
C896 a_15600_n37702.t4 VSS 0.40601f
C897 a_15600_n37702.t3 VSS 0.40602f
C898 a_15600_n37702.n0 VSS 0.38591f
C899 a_15600_n37702.n1 VSS 1.96623f
C900 a_15600_n37702.n2 VSS 0.27493f
C901 a_15600_n37702.t1 VSS 0.41173f
C902 a_18600_n37702.t0 VSS 0.40602f
C903 a_18600_n37702.t2 VSS 0.23054f
C904 a_18600_n37702.t4 VSS 0.41173f
C905 a_18600_n37702.t3 VSS 0.41173f
C906 a_18600_n37702.n0 VSS 0.27493f
C907 a_18600_n37702.n1 VSS 1.96623f
C908 a_18600_n37702.n2 VSS 0.38591f
C909 a_18600_n37702.t1 VSS 0.40601f
C910 a_21600_n37702.t0 VSS 0.40602f
C911 a_21600_n37702.t4 VSS 0.23054f
C912 a_21600_n37702.t3 VSS 0.41173f
C913 a_21600_n37702.t2 VSS 0.41173f
C914 a_21600_n37702.n0 VSS 0.27493f
C915 a_21600_n37702.n1 VSS 1.96623f
C916 a_21600_n37702.n2 VSS 0.38591f
C917 a_21600_n37702.t1 VSS 0.40601f
C918 a_24600_n37702.t0 VSS 0.40602f
C919 a_24600_n37702.t4 VSS 0.23054f
C920 a_24600_n37702.t3 VSS 0.41173f
C921 a_24600_n37702.t2 VSS 0.41173f
C922 a_24600_n37702.n0 VSS 0.27493f
C923 a_24600_n37702.n1 VSS 1.96623f
C924 a_24600_n37702.n2 VSS 0.38591f
C925 a_24600_n37702.t1 VSS 0.40601f
C926 a_31000_n37702.t1 VSS 0.40601f
C927 a_31000_n37702.t0 VSS 0.23054f
C928 a_31000_n37702.t4 VSS 0.41173f
C929 a_31000_n37702.t3 VSS 0.41173f
C930 a_31000_n37702.n0 VSS 0.27493f
C931 a_31000_n37702.n1 VSS 1.96623f
C932 a_31000_n37702.n2 VSS 0.38591f
C933 a_31000_n37702.t2 VSS 0.40602f
C934 a_34000_n37702.t0 VSS 0.40601f
C935 a_34000_n37702.t2 VSS 0.23054f
C936 a_34000_n37702.t4 VSS 0.41173f
C937 a_34000_n37702.t3 VSS 0.41173f
C938 a_34000_n37702.n0 VSS 0.27493f
C939 a_34000_n37702.n1 VSS 1.96623f
C940 a_34000_n37702.n2 VSS 0.38591f
C941 a_34000_n37702.t1 VSS 0.40602f
C942 a_37000_n37702.t0 VSS 0.41173f
C943 a_37000_n37702.t2 VSS 0.23054f
C944 a_37000_n37702.t4 VSS 0.40602f
C945 a_37000_n37702.t3 VSS 0.40601f
C946 a_37000_n37702.n0 VSS 0.38591f
C947 a_37000_n37702.n1 VSS 1.96623f
C948 a_37000_n37702.n2 VSS 0.27493f
C949 a_37000_n37702.t1 VSS 0.41173f
C950 a_40000_n37702.t0 VSS 0.41173f
C951 a_40000_n37702.t2 VSS 0.23054f
C952 a_40000_n37702.t4 VSS 0.40602f
C953 a_40000_n37702.t3 VSS 0.40601f
C954 a_40000_n37702.n0 VSS 0.38591f
C955 a_40000_n37702.n1 VSS 1.96623f
C956 a_40000_n37702.n2 VSS 0.27493f
C957 a_40000_n37702.t1 VSS 0.41173f
C958 a_43000_n37702.t0 VSS 0.41127f
C959 a_43000_n37702.t2 VSS 0.23035f
C960 a_43000_n37702.t4 VSS 0.4057f
C961 a_43000_n37702.t3 VSS 0.40569f
C962 a_43000_n37702.n0 VSS 0.38558f
C963 a_43000_n37702.n1 VSS 1.96457f
C964 a_43000_n37702.n2 VSS 0.27469f
C965 a_43000_n37702.t1 VSS 0.41127f
C966 VSS.t49 VSS 0.25581f
C967 VSS.t48 VSS 0.25581f
C968 VSS.t94 VSS 25.45585f
C969 VSS.t51 VSS 0.26459f
C970 VSS.t50 VSS 0.26459f
C971 VSS.t190 VSS 0.38643f
C972 VSS.t191 VSS 0.38643f
C973 VSS.t130 VSS 0.26168f
C974 VSS.t131 VSS 0.26168f
C975 VSS.t196 VSS 13.7208f
C976 VSS.t184 VSS 0.014f
C977 VSS.t182 VSS 0.01448f
C978 VSS.t188 VSS 0.01448f
C979 VSS.t186 VSS 0.014f
C980 VSS.t43 VSS 0.28512f
C981 VSS.t42 VSS 0.28512f
C982 VSS.t135 VSS 0.25843f
C983 VSS.t134 VSS 0.25843f
C984 VSS.t52 VSS 0.29508f
C985 VSS.t53 VSS 0.29508f
C986 VSS.t31 VSS 0.31581f
C987 VSS.t32 VSS 0.31581f
C988 VSS.t137 VSS 0.43292f
C989 VSS.t138 VSS 0.43292f
C990 VSS.t116 VSS 14.0013f
C991 VSS.t35 VSS 0.48007f
C992 VSS.t36 VSS 0.48007f
C993 VSS.t219 VSS 0.29852f
C994 VSS.t218 VSS 0.29852f
C995 VSS.t174 VSS 25.5473f
C996 VSS.t148 VSS 0.28924f
C997 VSS.t149 VSS 0.28924f
C998 VSS.t226 VSS 0.0102f
C999 VSS.t225 VSS 0.01055f
C1000 VSS.t227 VSS 0.01055f
C1001 VSS.t224 VSS 0.0102f
C1002 VSS.t71 VSS 0.02512f
C1003 VSS.t69 VSS 0.02549f
C1004 VSS.t67 VSS 0.02549f
C1005 VSS.t73 VSS 0.02512f
C1006 VSS.t129 VSS 0.43413f
C1007 VSS.t128 VSS 0.43413f
C1008 VSS.t210 VSS 0.28489f
C1009 VSS.t211 VSS 0.28489f
C1010 VSS.t37 VSS 0.25903f
C1011 VSS.t38 VSS 0.25903f
C1012 VSS.t13 VSS 0.19132f
C1013 VSS.t12 VSS 0.19132f
C1014 VDD.t8 VSS 0.01336f
C1015 VDD.t5 VSS 0.01336f
C1016 VDD.n0 VSS 0.52833f
C1017 VDD.t15 VSS 0.01336f
C1018 VDD.t12 VSS 0.01336f
C1019 VDD.n1 VSS 0.62515f
C1020 VDD.t1 VSS 0.01336f
C1021 VDD.t0 VSS 0.01336f
C1022 VDD.n2 VSS 0.52893f
C1023 VDD.n3 VSS 0.44922f
C1024 VDD.n4 VSS 0.21953f
C1025 VDD.t17 VSS 0.01336f
C1026 VDD.t3 VSS 0.01336f
C1027 VDD.n5 VSS 0.62456f
C1028 VDD.n6 VSS 0.73588f
C1029 VDD.t9 VSS 0.02124f
C1030 VDD.t19 VSS 0.02026f
C1031 VDD.n7 VSS 0.11206f
C1032 VDD.t11 VSS 0.02339f
C1033 VDD.t13 VSS 0.02054f
C1034 VDD.n8 VSS 0.12962f
C1035 VDD.n9 VSS 0.06693f
C1036 VDD.t10 VSS 0.01336f
C1037 VDD.t7 VSS 0.01336f
C1038 VDD.n10 VSS 0.52772f
C1039 VDD.t14 VSS 0.01336f
C1040 VDD.t6 VSS 0.01336f
C1041 VDD.n11 VSS 0.62453f
C1042 VDD.t4 VSS 0.01336f
C1043 VDD.t2 VSS 0.01336f
C1044 VDD.n12 VSS 0.52832f
C1045 VDD.n13 VSS 0.44922f
C1046 VDD.n14 VSS 0.21953f
C1047 VDD.t16 VSS 0.01336f
C1048 VDD.t18 VSS 0.01336f
C1049 VDD.n15 VSS 0.62394f
C1050 VDD.n16 VSS 0.6811f
C1051 VDD.n17 VSS 0.78729f
C1052 CLK_P.t4 VSS 0.14392f
C1053 CLK_P.t2 VSS 0.25293f
C1054 CLK_P.t1 VSS 0.25303f
C1055 CLK_P.n0 VSS 0.18365f
C1056 CLK_P.t0 VSS 0.25295f
C1057 CLK_P.t3 VSS 0.25299f
C1058 CLK_P.n1 VSS 0.16501f
C1059 CLK_P.n2 VSS 0.76881f
C1060 CLK_N.t2 VSS 0.13565f
C1061 CLK_N.t4 VSS 0.24399f
C1062 CLK_N.t3 VSS 0.24403f
C1063 CLK_N.n0 VSS 0.15553f
C1064 CLK_N.t1 VSS 0.24407f
C1065 CLK_N.t0 VSS 0.24398f
C1066 CLK_N.n1 VSS 0.1731f
C1067 CLK_N.n2 VSS 0.72464f
C1068 SEL_BUF.n0 VSS 0.02249f
C1069 SEL_BUF.n1 VSS 0.02413f
C1070 SEL_BUF.n2 VSS 0.02413f
C1071 SEL_BUF.n3 VSS 0.02249f
C1072 SEL_BUF.n4 VSS 0.07784f
C1073 SEL_A.n0 VSS 0.01531f
C1074 SEL_A.n1 VSS 0.01724f
C1075 SEL_A.n2 VSS 0.01724f
C1076 SEL_A.n3 VSS 0.01531f
C1077 SEL_A.n4 VSS 0.12574f
C1078 SEL_B.n0 VSS 0.01115f
C1079 SEL_B.n1 VSS 0.01255f
C1080 SEL_B.n2 VSS 0.01255f
C1081 SEL_B.n3 VSS 0.01115f
C1082 SEL_B.n4 VSS 0.12976f
C1083 VREFL.t31 VSS 0.09625f
C1084 VREFL.t30 VSS 0.09624f
C1085 VREFL.n0 VSS 0.3804f
C1086 VREFL.t40 VSS 0.09625f
C1087 VREFL.t41 VSS 0.09624f
C1088 VREFL.n1 VSS 0.27658f
C1089 VREFL.n2 VSS 1.3679f
C1090 VREFL.t43 VSS 0.09625f
C1091 VREFL.t42 VSS 0.09624f
C1092 VREFL.n3 VSS 0.27658f
C1093 VREFL.n4 VSS 0.77299f
C1094 VREFL.t24 VSS 0.09625f
C1095 VREFL.t25 VSS 0.09624f
C1096 VREFL.n5 VSS 0.27658f
C1097 VREFL.n6 VSS 0.77299f
C1098 VREFL.t32 VSS 0.09625f
C1099 VREFL.t33 VSS 0.09624f
C1100 VREFL.n7 VSS 0.27658f
C1101 VREFL.n8 VSS 0.67399f
C1102 VREFL.t2 VSS 0.81702f
C1103 VREFL.n9 VSS 1.98912f
C1104 VREFL.t27 VSS 0.81702f
C1105 VREFL.n10 VSS 1.98912f
C1106 VREFL.t1 VSS 0.09624f
C1107 VREFL.t0 VSS 0.09625f
C1108 VREFL.n11 VSS 0.27658f
C1109 VREFL.n12 VSS 0.67399f
C1110 VREFL.t4 VSS 0.09624f
C1111 VREFL.t3 VSS 0.09625f
C1112 VREFL.n13 VSS 0.27658f
C1113 VREFL.n14 VSS 0.77299f
C1114 VREFL.t23 VSS 0.09624f
C1115 VREFL.t22 VSS 0.09625f
C1116 VREFL.n15 VSS 0.27658f
C1117 VREFL.n16 VSS 0.77299f
C1118 VREFL.t38 VSS 0.09624f
C1119 VREFL.t39 VSS 0.09625f
C1120 VREFL.n17 VSS 0.27658f
C1121 VREFL.n18 VSS 0.77299f
C1122 VREFL.t7 VSS 0.09624f
C1123 VREFL.t8 VSS 0.09625f
C1124 VREFL.n19 VSS 0.27658f
C1125 VREFL.n20 VSS 2.10945f
C1126 VREFL.t20 VSS 0.09624f
C1127 VREFL.t19 VSS 0.09625f
C1128 VREFL.n21 VSS 0.3804f
C1129 VREFL.t10 VSS 0.09624f
C1130 VREFL.t9 VSS 0.09625f
C1131 VREFL.n22 VSS 0.27658f
C1132 VREFL.n23 VSS 1.3679f
C1133 VREFL.t36 VSS 0.09624f
C1134 VREFL.t37 VSS 0.09625f
C1135 VREFL.n24 VSS 0.27658f
C1136 VREFL.n25 VSS 0.77299f
C1137 VREFL.t16 VSS 0.09624f
C1138 VREFL.t15 VSS 0.09625f
C1139 VREFL.n26 VSS 0.27658f
C1140 VREFL.n27 VSS 0.77299f
C1141 VREFL.t5 VSS 0.09624f
C1142 VREFL.t6 VSS 0.09625f
C1143 VREFL.n28 VSS 0.27658f
C1144 VREFL.n29 VSS 0.67399f
C1145 VREFL.t26 VSS 0.81702f
C1146 VREFL.n30 VSS 1.98912f
C1147 VREFL.t21 VSS 0.81702f
C1148 VREFL.n31 VSS 1.98912f
C1149 VREFL.t29 VSS 0.09625f
C1150 VREFL.t28 VSS 0.09624f
C1151 VREFL.n32 VSS 0.27658f
C1152 VREFL.n33 VSS 0.67399f
C1153 VREFL.t12 VSS 0.09625f
C1154 VREFL.t11 VSS 0.09624f
C1155 VREFL.n34 VSS 0.27658f
C1156 VREFL.n35 VSS 0.77299f
C1157 VREFL.t14 VSS 0.09625f
C1158 VREFL.t13 VSS 0.09624f
C1159 VREFL.n36 VSS 0.27658f
C1160 VREFL.n37 VSS 0.77299f
C1161 VREFL.t35 VSS 0.09625f
C1162 VREFL.t34 VSS 0.09624f
C1163 VREFL.n38 VSS 0.27658f
C1164 VREFL.n39 VSS 0.77299f
C1165 VREFL.t17 VSS 0.09625f
C1166 VREFL.t18 VSS 0.09624f
C1167 VREFL.n40 VSS 0.27658f
C1168 VREFL.n41 VSS 1.86195f
C1169 F_A4.n0 VSS 0.16193f
C1170 F_A3.n0 VSS 0.1626f
C1171 F_A2.n0 VSS 0.1626f
C1172 F_A1.n0 VSS 0.1626f
C1173 F_A0.n0 VSS 0.1626f
C1174 F_B0.n0 VSS 0.1626f
C1175 F_B1.n0 VSS 0.1626f
C1176 F_B2.n0 VSS 0.1626f
C1177 F_B3.n0 VSS 0.1626f
C1178 F_B4.n0 VSS 0.16245f
C1179 VREFH.t5 VSS 0.1271f
C1180 VREFH.t4 VSS 0.12711f
C1181 VREFH.n0 VSS 0.52242f
C1182 VREFH.t19 VSS 0.12725f
C1183 VREFH.t20 VSS 0.12725f
C1184 VREFH.n1 VSS 0.37984f
C1185 VREFH.n2 VSS 1.87863f
C1186 VREFH.t11 VSS 0.12725f
C1187 VREFH.t12 VSS 0.12725f
C1188 VREFH.n3 VSS 0.37984f
C1189 VREFH.n4 VSS 1.06159f
C1190 VREFH.t35 VSS 0.12725f
C1191 VREFH.t36 VSS 0.12725f
C1192 VREFH.n5 VSS 0.37984f
C1193 VREFH.n6 VSS 1.06159f
C1194 VREFH.t33 VSS 0.12725f
C1195 VREFH.t34 VSS 0.12725f
C1196 VREFH.n7 VSS 0.37984f
C1197 VREFH.n8 VSS 1.63942f
C1198 VREFH.t10 VSS 0.12725f
C1199 VREFH.t9 VSS 0.12725f
C1200 VREFH.n9 VSS 0.37984f
C1201 VREFH.n10 VSS 1.63942f
C1202 VREFH.t13 VSS 0.12725f
C1203 VREFH.t14 VSS 0.12725f
C1204 VREFH.n11 VSS 0.37984f
C1205 VREFH.n12 VSS 1.06159f
C1206 VREFH.t38 VSS 0.12725f
C1207 VREFH.t37 VSS 0.12725f
C1208 VREFH.n13 VSS 0.37984f
C1209 VREFH.n14 VSS 1.06159f
C1210 VREFH.t2 VSS 0.12725f
C1211 VREFH.t3 VSS 0.12725f
C1212 VREFH.n15 VSS 0.37984f
C1213 VREFH.n16 VSS 1.06159f
C1214 VREFH.t7 VSS 0.12725f
C1215 VREFH.t8 VSS 0.12725f
C1216 VREFH.n17 VSS 0.37984f
C1217 VREFH.n18 VSS 2.89703f
C1218 VREFH.t0 VSS 0.12711f
C1219 VREFH.t21 VSS 0.1271f
C1220 VREFH.n19 VSS 0.52242f
C1221 VREFH.t23 VSS 0.12725f
C1222 VREFH.t1 VSS 0.12725f
C1223 VREFH.n20 VSS 0.37984f
C1224 VREFH.n21 VSS 1.87863f
C1225 VREFH.t17 VSS 0.12725f
C1226 VREFH.t39 VSS 0.12725f
C1227 VREFH.n22 VSS 0.37984f
C1228 VREFH.n23 VSS 1.06159f
C1229 VREFH.t15 VSS 0.12725f
C1230 VREFH.t26 VSS 0.12725f
C1231 VREFH.n24 VSS 0.37984f
C1232 VREFH.n25 VSS 1.06159f
C1233 VREFH.t32 VSS 0.12725f
C1234 VREFH.t30 VSS 0.12725f
C1235 VREFH.n26 VSS 0.37984f
C1236 VREFH.n27 VSS 1.63942f
C1237 VREFH.t28 VSS 0.12725f
C1238 VREFH.t24 VSS 0.12725f
C1239 VREFH.n28 VSS 0.37984f
C1240 VREFH.n29 VSS 1.63942f
C1241 VREFH.t22 VSS 0.12725f
C1242 VREFH.t16 VSS 0.12725f
C1243 VREFH.n30 VSS 0.37984f
C1244 VREFH.n31 VSS 1.06159f
C1245 VREFH.t27 VSS 0.12725f
C1246 VREFH.t18 VSS 0.12725f
C1247 VREFH.n32 VSS 0.37984f
C1248 VREFH.n33 VSS 1.06159f
C1249 VREFH.t25 VSS 0.12725f
C1250 VREFH.t31 VSS 0.12725f
C1251 VREFH.n34 VSS 0.37984f
C1252 VREFH.n35 VSS 1.06159f
C1253 VREFH.t29 VSS 0.12721f
C1254 VREFH.t6 VSS 0.12722f
C1255 VREFH.n36 VSS 0.37984f
C1256 VREFH.n37 VSS 2.55714f
C1257 F_A4B.n0 VSS 0.12145f
C1258 F_A3B.n0 VSS 0.12145f
C1259 F_A2B.n0 VSS 0.12145f
C1260 F_A1B.n0 VSS 0.12145f
C1261 F_A0B.n0 VSS 0.12145f
C1262 F_B0B.n0 VSS 0.12145f
C1263 F_B1B.n0 VSS 0.12145f
C1264 F_B2B.n0 VSS 0.12145f
C1265 F_B3B.n0 VSS 0.12145f
C1266 F_B4B.n0 VSS 0.12145f
C1267 G_A4.n0 VSS 0.1626f
C1268 G_A3.n0 VSS 0.1626f
C1269 G_A2.n0 VSS 0.1626f
C1270 G_A1.n0 VSS 0.1626f
C1271 G_A0.n0 VSS 0.1626f
C1272 G_B0.n0 VSS 0.1626f
C1273 G_B1.n0 VSS 0.1626f
C1274 G_B2.n0 VSS 0.1626f
C1275 G_B3.n0 VSS 0.1626f
C1276 G_B4.n0 VSS 0.16193f
C1277 G_A4B.n0 VSS 0.12145f
C1278 G_A3B.n0 VSS 0.12145f
C1279 G_A2B.n0 VSS 0.12145f
C1280 G_A1B.n0 VSS 0.12145f
C1281 G_A0B.n0 VSS 0.12145f
C1282 G_B0B.n0 VSS 0.12145f
C1283 G_B1B.n0 VSS 0.12145f
C1284 G_B2B.n0 VSS 0.12145f
C1285 G_B3B.n0 VSS 0.12145f
C1286 G_B4B.n0 VSS 0.12145f
.ends
