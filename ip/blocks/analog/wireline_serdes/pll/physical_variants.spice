* SPDX-License-Identifier: Apache-2.0
* Fixed physical VCO delay-tile variants used for LVS and extracted simulation.

.subckt cml_vco_delay_fast INP INN OUTP OUTN VCTRL VDD VSS
XRP VDD OUTP VSS ppolyf_u r_width=2u r_length=5.25u
XRN VDD OUTN VSS ppolyf_u r_width=2u r_length=5.25u
XMP OUTP INP TAIL VSS nfet_03v3 w=5u l=0.28u m=2
XMN OUTN INN TAIL VSS nfet_03v3 w=5u l=0.28u m=2
XMT TAIL VCTRL VSS VSS nfet_03v3 w=10u l=0.28u m=4
XLP OUTP OUTN LTAIL VSS nfet_03v3 w=4u l=0.28u m=1
XLN OUTN OUTP LTAIL VSS nfet_03v3 w=4u l=0.28u m=1
XMLT LTAIL VCTRL VSS VSS nfet_03v3 w=4u l=0.28u m=2
XCP VSS OUTP VSS VSS nfet_03v3 w=4u l=0.6u m=1
XCN VSS OUTN VSS VSS nfet_03v3 w=4u l=0.6u m=1
.ends cml_vco_delay_fast

.subckt cml_vco_delay_ultra_fast INP INN OUTP OUTN VCTRL VDD VSS
XRP VDD OUTP VSS ppolyf_u r_width=2u r_length=4.25u
XRN VDD OUTN VSS ppolyf_u r_width=2u r_length=4.25u
XMP OUTP INP TAIL VSS nfet_03v3 w=5u l=0.28u m=2
XMN OUTN INN TAIL VSS nfet_03v3 w=5u l=0.28u m=2
XMT TAIL VCTRL VSS VSS nfet_03v3 w=10u l=0.28u m=4
XLP OUTP OUTN LTAIL VSS nfet_03v3 w=4u l=0.28u m=1
XLN OUTN OUTP LTAIL VSS nfet_03v3 w=4u l=0.28u m=1
XMLT LTAIL VCTRL VSS VSS nfet_03v3 w=4u l=0.28u m=2
XCP VSS OUTP VSS VSS nfet_03v3 w=4u l=0.5u m=1
XCN VSS OUTN VSS VSS nfet_03v3 w=4u l=0.5u m=1
.ends cml_vco_delay_ultra_fast

.subckt cml_vco_delay_slow INP INN OUTP OUTN VCTRL VDD VSS
XRP VDD OUTP VSS ppolyf_u r_width=2u r_length=5.25u
XRN VDD OUTN VSS ppolyf_u r_width=2u r_length=5.25u
XMP OUTP INP TAIL VSS nfet_03v3 w=5u l=0.28u m=2
XMN OUTN INN TAIL VSS nfet_03v3 w=5u l=0.28u m=2
XMT TAIL VCTRL VSS VSS nfet_03v3 w=10u l=0.28u m=4
XLP OUTP OUTN LTAIL VSS nfet_03v3 w=4u l=0.28u m=1
XLN OUTN OUTP LTAIL VSS nfet_03v3 w=4u l=0.28u m=1
XMLT LTAIL VCTRL VSS VSS nfet_03v3 w=4u l=0.28u m=2
XCP VSS OUTP VSS VSS nfet_03v3 w=4u l=2.4u m=1
XCN VSS OUTN VSS VSS nfet_03v3 w=4u l=2.4u m=1
.ends cml_vco_delay_slow

.subckt cml_vco_delay_high_gain INP INN OUTP OUTN VCTRL VDD VSS
XRP VDD OUTP VSS ppolyf_u r_width=2u r_length=6.5u
XRN VDD OUTN VSS ppolyf_u r_width=2u r_length=6.5u
XMP OUTP INP TAIL VSS nfet_03v3 w=5u l=0.28u m=2
XMN OUTN INN TAIL VSS nfet_03v3 w=5u l=0.28u m=2
XMT TAIL VCTRL VSS VSS nfet_03v3 w=10u l=0.28u m=4
XLP OUTP OUTN LTAIL VSS nfet_03v3 w=4u l=0.28u m=1
XLN OUTN OUTP LTAIL VSS nfet_03v3 w=4u l=0.28u m=1
XMLT LTAIL VCTRL VSS VSS nfet_03v3 w=4u l=0.28u m=2
XCP VSS OUTP VSS VSS nfet_03v3 w=4u l=0.5u m=1
XCN VSS OUTN VSS VSS nfet_03v3 w=4u l=0.5u m=1
.ends cml_vco_delay_high_gain

.subckt cml_vco_delay_ss_ff INP INN OUTP OUTN VCTRL VDD VSS
XRP VDD OUTP VSS ppolyf_u r_width=2u r_length=6.25u
XRN VDD OUTN VSS ppolyf_u r_width=2u r_length=6.25u
XMP OUTP INP TAIL VSS nfet_03v3 w=5u l=0.28u m=2
XMN OUTN INN TAIL VSS nfet_03v3 w=5u l=0.28u m=2
XMT TAIL VCTRL VSS VSS nfet_03v3 w=15u l=0.28u m=4
XLP OUTP OUTN LTAIL VSS nfet_03v3 w=4u l=0.28u m=1
XLN OUTN OUTP LTAIL VSS nfet_03v3 w=4u l=0.28u m=1
XMLT LTAIL VCTRL VSS VSS nfet_03v3 w=5u l=0.28u m=2
XCP VSS OUTP VSS VSS nfet_03v3 w=4u l=0.37u m=1
XCN VSS OUTN VSS VSS nfet_03v3 w=4u l=0.37u m=1
.ends cml_vco_delay_ss_ff

.subckt cml_vco_delay_ss_ss INP INN OUTP OUTN VCTRL VDD VSS
XRP VDD OUTP VSS ppolyf_u r_width=2u r_length=4.0u
XRN VDD OUTN VSS ppolyf_u r_width=2u r_length=4.0u
XMP OUTP INP TAIL VSS nfet_03v3 w=5u l=0.28u m=2
XMN OUTN INN TAIL VSS nfet_03v3 w=5u l=0.28u m=2
XMT TAIL VCTRL VSS VSS nfet_03v3 w=15u l=0.28u m=4
XLP OUTP OUTN LTAIL VSS nfet_03v3 w=4u l=0.28u m=1
XLN OUTN OUTP LTAIL VSS nfet_03v3 w=4u l=0.28u m=1
XMLT LTAIL VCTRL VSS VSS nfet_03v3 w=6u l=0.28u m=2
XCP VSS OUTP VSS VSS nfet_03v3 w=4u l=0.38u m=1
XCN VSS OUTN VSS VSS nfet_03v3 w=4u l=0.38u m=1
.ends cml_vco_delay_ss_ss

.subckt cml_vco_delay_margin_slow INP INN OUTP OUTN VCTRL VDD VSS
XRP VDD OUTP VSS ppolyf_u r_width=2u r_length=4.0u
XRN VDD OUTN VSS ppolyf_u r_width=2u r_length=4.0u
XMP OUTP INP TAIL VSS nfet_03v3 w=5u l=0.28u m=2
XMN OUTN INN TAIL VSS nfet_03v3 w=5u l=0.28u m=2
XMT TAIL VCTRL VSS VSS nfet_03v3 w=15u l=0.28u m=4
XLP OUTP OUTN LTAIL VSS nfet_03v3 w=4u l=0.28u m=1
XLN OUTN OUTP LTAIL VSS nfet_03v3 w=4u l=0.28u m=1
XMLT LTAIL VCTRL VSS VSS nfet_03v3 w=6u l=0.28u m=2
XCP VSS OUTP VSS VSS nfet_03v3 w=4u l=0.5u m=1
XCN VSS OUTN VSS VSS nfet_03v3 w=4u l=0.5u m=1
.ends cml_vco_delay_margin_slow

.subckt cml_vco_delay_margin_fast INP INN OUTP OUTN VCTRL VDD VSS
XRP VDD OUTP VSS ppolyf_u r_width=2u r_length=4.0u
XRN VDD OUTN VSS ppolyf_u r_width=2u r_length=4.0u
XMP OUTP INP TAIL VSS nfet_03v3 w=5u l=0.28u m=2
XMN OUTN INN TAIL VSS nfet_03v3 w=5u l=0.28u m=2
XMT TAIL VCTRL VSS VSS nfet_03v3 w=15u l=0.28u m=4
XLP OUTP OUTN LTAIL VSS nfet_03v3 w=4u l=0.28u m=1
XLN OUTN OUTP LTAIL VSS nfet_03v3 w=4u l=0.28u m=1
XMLT LTAIL VCTRL VSS VSS nfet_03v3 w=6u l=0.28u m=2
XCP VSS OUTP VSS VSS nfet_03v3 w=3.2u l=0.37u m=1
XCN VSS OUTN VSS VSS nfet_03v3 w=3.2u l=0.37u m=1
.ends cml_vco_delay_margin_fast
