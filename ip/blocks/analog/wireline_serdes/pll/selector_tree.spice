* SPDX-License-Identifier: Apache-2.0
* Balanced 16-leaf selector tree: twelve VCO bands and four tied-off spares.
.include /src/pll/selector_unit.spice

.subckt vco_selector_tree
+ I0P I0N I1P I1N I2P I2N I3P I3N I4P I4N I5P I5N
+ I6P I6N I7P I7N I8P I8N I9P I9N I10P I10N I11P I11N VDUMMY
+ S0A S0B S0BUF S1A S1B S1BUF S2A S2B S2BUF S3A S3B S3BUF
+ S4A S4B S4BUF S5A S5B S5BUF S6A S6B S6BUF S7A S7B S7BUF
+ S8A S8B S8BUF S9A S9B S9BUF S10A S10B S10BUF S11A S11B S11BUF
+ S12A S12B S12BUF S13A S13B S13BUF S14A S14B S14BUF
+ VDD VSS OUTP OUTN

X0 I0P I0N I1P I1N S0A S0B S0BUF VDD VSS L0P L0N vco_selector_unit
X1 I2P I2N I3P I3N S1A S1B S1BUF VDD VSS L1P L1N vco_selector_unit
X2 I4P I4N I5P I5N S2A S2B S2BUF VDD VSS L2P L2N vco_selector_unit
X3 I6P I6N I7P I7N S3A S3B S3BUF VDD VSS L3P L3N vco_selector_unit
X4 I8P I8N I9P I9N S4A S4B S4BUF VDD VSS L4P L4N vco_selector_unit
X5 I10P I10N I11P I11N S5A S5B S5BUF VDD VSS L5P L5N vco_selector_unit
X6 VDUMMY VDUMMY VDUMMY VDUMMY S6A S6B S6BUF VDD VSS L6P L6N vco_selector_unit
X7 VDUMMY VDUMMY VDUMMY VDUMMY S7A S7B S7BUF VDD VSS L7P L7N vco_selector_unit

X8 L0P L0N L1P L1N S8A S8B S8BUF VDD VSS Q0P Q0N vco_selector_unit
X9 L2P L2N L3P L3N S9A S9B S9BUF VDD VSS Q1P Q1N vco_selector_unit
X10 L4P L4N L5P L5N S10A S10B S10BUF VDD VSS Q2P Q2N vco_selector_unit
X11 L6P L6N L7P L7N S11A S11B S11BUF VDD VSS Q3P Q3N vco_selector_unit

X12 Q0P Q0N Q1P Q1N S12A S12B S12BUF VDD VSS R0P R0N vco_selector_unit
X13 Q2P Q2N Q3P Q3N S13A S13B S13BUF VDD VSS R1P R1N vco_selector_unit
X14 R0P R0N R1P R1N S14A S14B S14BUF VDD VSS OUTP OUTN vco_selector_unit
.ends vco_selector_tree
