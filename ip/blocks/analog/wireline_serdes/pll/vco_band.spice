* SPDX-License-Identifier: Apache-2.0
* Physical three-stage CML ring, output buffer, and deterministic startup pair.
.include /src/pll/physical_variants.spice
.include /src/pll/startup_assist.spice

.subckt cml_vco_band VCTRL KICKP KICKN VDD VSS CLK_P CLK_N
X0 N2P N2N N0P N0N VCTRL VDD VSS cml_vco_delay_margin_fast
X1 N0P N0N N1P N1N VCTRL VDD VSS cml_vco_delay_margin_fast
X2 N1P N1N N2P N2N VCTRL VDD VSS cml_vco_delay_margin_fast
XBUF N2P N2N CLK_P CLK_N VCTRL VDD VSS cml_vco_delay_margin_fast
XSTART N0P N0N KICKP KICKN VSS cml_vco_startup_assist
.ends cml_vco_band
