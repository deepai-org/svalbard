* SPDX-License-Identifier: Apache-2.0
* Complete routed-band schematic variants: three ring stages, buffer, assist.
.include /src/pll/ring_vco.spice
.include /src/pll/physical_variants.spice
.include /src/pll/startup_assist.spice

.subckt cml_vco_band_center VCTRL KICKP KICKN VDD VSS CLK_P CLK_N
X0 N2P N2N N0P N0N VCTRL VDD VSS cml_vco_delay
X1 N0P N0N N1P N1N VCTRL VDD VSS cml_vco_delay
X2 N1P N1N N2P N2N VCTRL VDD VSS cml_vco_delay
XBUF N2P N2N CLK_P CLK_N VCTRL VDD VSS cml_vco_delay
XSTART N0P N0N KICKP KICKN VSS cml_vco_startup_assist
.ends cml_vco_band_center

.subckt cml_vco_band_fast VCTRL KICKP KICKN VDD VSS CLK_P CLK_N
X0 N2P N2N N0P N0N VCTRL VDD VSS cml_vco_delay_fast
X1 N0P N0N N1P N1N VCTRL VDD VSS cml_vco_delay_fast
X2 N1P N1N N2P N2N VCTRL VDD VSS cml_vco_delay_fast
XBUF N2P N2N CLK_P CLK_N VCTRL VDD VSS cml_vco_delay_fast
XSTART N0P N0N KICKP KICKN VSS cml_vco_startup_assist
.ends cml_vco_band_fast

.subckt cml_vco_band_ultra_fast VCTRL KICKP KICKN VDD VSS CLK_P CLK_N
X0 N2P N2N N0P N0N VCTRL VDD VSS cml_vco_delay_ultra_fast
X1 N0P N0N N1P N1N VCTRL VDD VSS cml_vco_delay_ultra_fast
X2 N1P N1N N2P N2N VCTRL VDD VSS cml_vco_delay_ultra_fast
XBUF N2P N2N CLK_P CLK_N VCTRL VDD VSS cml_vco_delay_ultra_fast
XSTART N0P N0N KICKP KICKN VSS cml_vco_startup_assist
.ends cml_vco_band_ultra_fast

.subckt cml_vco_band_slow VCTRL KICKP KICKN VDD VSS CLK_P CLK_N
X0 N2P N2N N0P N0N VCTRL VDD VSS cml_vco_delay_slow
X1 N0P N0N N1P N1N VCTRL VDD VSS cml_vco_delay_slow
X2 N1P N1N N2P N2N VCTRL VDD VSS cml_vco_delay_slow
XBUF N2P N2N CLK_P CLK_N VCTRL VDD VSS cml_vco_delay_slow
XSTART N0P N0N KICKP KICKN VSS cml_vco_startup_assist
.ends cml_vco_band_slow

.subckt cml_vco_band_high_gain VCTRL KICKP KICKN VDD VSS CLK_P CLK_N
X0 N2P N2N N0P N0N VCTRL VDD VSS cml_vco_delay_high_gain
X1 N0P N0N N1P N1N VCTRL VDD VSS cml_vco_delay_high_gain
X2 N1P N1N N2P N2N VCTRL VDD VSS cml_vco_delay_high_gain
XBUF N2P N2N CLK_P CLK_N VCTRL VDD VSS cml_vco_delay_high_gain
XSTART N0P N0N KICKP KICKN VSS cml_vco_startup_assist
.ends cml_vco_band_high_gain

.subckt cml_vco_band_ss_ff VCTRL KICKP KICKN VDD VSS CLK_P CLK_N
X0 N2P N2N N0P N0N VCTRL VDD VSS cml_vco_delay_ss_ff
X1 N0P N0N N1P N1N VCTRL VDD VSS cml_vco_delay_ss_ff
X2 N1P N1N N2P N2N VCTRL VDD VSS cml_vco_delay_ss_ff
XBUF N2P N2N CLK_P CLK_N VCTRL VDD VSS cml_vco_delay_ss_ff
XSTART N0P N0N KICKP KICKN VSS cml_vco_startup_assist
.ends cml_vco_band_ss_ff

.subckt cml_vco_band_ss_ss VCTRL KICKP KICKN VDD VSS CLK_P CLK_N
X0 N2P N2N N0P N0N VCTRL VDD VSS cml_vco_delay_ss_ss
X1 N0P N0N N1P N1N VCTRL VDD VSS cml_vco_delay_ss_ss
X2 N1P N1N N2P N2N VCTRL VDD VSS cml_vco_delay_ss_ss
XBUF N2P N2N CLK_P CLK_N VCTRL VDD VSS cml_vco_delay_ss_ss
XSTART N0P N0N KICKP KICKN VSS cml_vco_startup_assist
.ends cml_vco_band_ss_ss

.subckt cml_vco_band_margin_slow VCTRL KICKP KICKN VDD VSS CLK_P CLK_N
X0 N2P N2N N0P N0N VCTRL VDD VSS cml_vco_delay_margin_slow
X1 N0P N0N N1P N1N VCTRL VDD VSS cml_vco_delay_margin_slow
X2 N1P N1N N2P N2N VCTRL VDD VSS cml_vco_delay_margin_slow
XBUF N2P N2N CLK_P CLK_N VCTRL VDD VSS cml_vco_delay_margin_slow
XSTART N0P N0N KICKP KICKN VSS cml_vco_startup_assist
.ends cml_vco_band_margin_slow

.subckt cml_vco_band_margin_fast VCTRL KICKP KICKN VDD VSS CLK_P CLK_N
X0 N2P N2N N0P N0N VCTRL VDD VSS cml_vco_delay_margin_fast
X1 N0P N0N N1P N1N VCTRL VDD VSS cml_vco_delay_margin_fast
X2 N1P N1N N2P N2N VCTRL VDD VSS cml_vco_delay_margin_fast
XBUF N2P N2N CLK_P CLK_N VCTRL VDD VSS cml_vco_delay_margin_fast
XSTART N0P N0N KICKP KICKN VSS cml_vco_startup_assist
.ends cml_vco_band_margin_fast

.subckt cml_vco_band_typ_margin_slow VCTRL KICKP KICKN VDD VSS CLK_P CLK_N
X0 N2P N2N N0P N0N VCTRL VDD VSS cml_vco_delay_typ_margin_slow
X1 N0P N0N N1P N1N VCTRL VDD VSS cml_vco_delay_typ_margin_slow
X2 N1P N1N N2P N2N VCTRL VDD VSS cml_vco_delay_typ_margin_slow
XBUF N2P N2N CLK_P CLK_N VCTRL VDD VSS cml_vco_delay_typ_margin_slow
XSTART N0P N0N KICKP KICKN VSS cml_vco_startup_assist
.ends cml_vco_band_typ_margin_slow

.subckt cml_vco_band_ss_ff_margin_slow VCTRL KICKP KICKN VDD VSS CLK_P CLK_N
X0 N2P N2N N0P N0N VCTRL VDD VSS cml_vco_delay_ss_ff_margin_slow
X1 N0P N0N N1P N1N VCTRL VDD VSS cml_vco_delay_ss_ff_margin_slow
X2 N1P N1N N2P N2N VCTRL VDD VSS cml_vco_delay_ss_ff_margin_slow
XBUF N2P N2N CLK_P CLK_N VCTRL VDD VSS cml_vco_delay_ss_ff_margin_slow
XSTART N0P N0N KICKP KICKN VSS cml_vco_startup_assist
.ends cml_vco_band_ss_ff_margin_slow

.subckt cml_vco_band_ss_ff_margin_fast VCTRL KICKP KICKN VDD VSS CLK_P CLK_N
X0 N2P N2N N0P N0N VCTRL VDD VSS cml_vco_delay_ss_ff_margin_fast
X1 N0P N0N N1P N1N VCTRL VDD VSS cml_vco_delay_ss_ff_margin_fast
X2 N1P N1N N2P N2N VCTRL VDD VSS cml_vco_delay_ss_ff_margin_fast
XBUF N2P N2N CLK_P CLK_N VCTRL VDD VSS cml_vco_delay_ss_ff_margin_fast
XSTART N0P N0N KICKP KICKN VSS cml_vco_startup_assist
.ends cml_vco_band_ss_ff_margin_fast
