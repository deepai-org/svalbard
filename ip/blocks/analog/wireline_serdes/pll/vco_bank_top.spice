* SPDX-License-Identifier: Apache-2.0
* Selected two-member half-rate VCO bank with physical bias DACs and selector.
.include /src/phase_control_dac/phase_control_dac.spice
.include /src/pll/split_control_vco.spice
.include /src/phase_interpolator/phase_interpolator.spice

.subckt vco_bank_top VREFH VREFL VDD VSS
+ F_A4 F_A4B F_A3 F_A3B F_A2 F_A2B F_A1 F_A1B F_A0 F_A0B
+ F_B4 F_B4B F_B3 F_B3B F_B2 F_B2B F_B1 F_B1B F_B0 F_B0B
+ G_A4 G_A4B G_A3 G_A3B G_A2 G_A2B G_A1 G_A1B G_A0 G_A0B
+ G_B4 G_B4B G_B3 G_B3B G_B2 G_B2B G_B1 G_B1B G_B0 G_B0B
+ FAST_KICKP FAST_KICKN GAIN_KICKP GAIN_KICKN
+ SEL_A SEL_B SEL_BUF CLK_P CLK_N

XFDAC F_A4 F_A4B F_A3 F_A3B F_A2 F_A2B F_A1 F_A1B F_A0 F_A0B
+ F_B4 F_B4B F_B3 F_B3B F_B2 F_B2B F_B1 F_B1B F_B0 F_B0B
+ VREFH VREFL VSS F_MAIN F_REGEN phase_control_dac
XGDAC G_A4 G_A4B G_A3 G_A3B G_A2 G_A2B G_A1 G_A1B G_A0 G_A0B
+ G_B4 G_B4B G_B3 G_B3B G_B2 G_B2B G_B1 G_B1B G_B0 G_B0B
+ VREFH VREFL VSS G_MAIN G_REGEN phase_control_dac

XFAST F_MAIN FAST_KICKP FAST_KICKN VDD VSS FCLK_P FCLK_N F_REGEN
+ cml_vco_band_hr_split_fast
XGAIN G_MAIN GAIN_KICKP GAIN_KICKN VDD VSS GCLK_P GCLK_N G_REGEN
+ cml_vco_band_hr_split_gain
XSEL FCLK_P FCLK_N GCLK_P GCLK_N SEL_A SEL_B SEL_BUF VDD VSS
+ CLK_P CLK_N phase_interpolator
.ends vco_bank_top
