* PEX produced using /foss/tools/sak/sak-pex.sh with m=3 and s=1 (extresist threshold=0 mOhm, minres=1 mOhm, mindelay=0 ps)
* NGSPICE file created from reference_level_receiver_pex.ext - technology: gf180mcuD

.subckt reference_level_receiver_pex IN REF VBIAS VDD VSS OUTP OUTN
X0 VSS.t7 a_n9316_3400.t3 a_n7796_3000.t2 VSS.t6 nfet_03v3 ad=1.56p pd=6.52u as=2.64p ps=12.88u w=6u l=0.28u
X1 a_n1172_n800.t2 VBIAS.t0 VSS.t28 VSS.t27 nfet_03v3 ad=5.28p pd=24.88u as=3.12p ps=12.52u w=12u l=0.28u
X2 VDD.t21 a_n7796_3000.t7 OUTN.t1 VDD.t20 pfet_03v3 ad=3.52p pd=16.88u as=2.08p ps=8.52u w=8u l=0.28u
X3 OUTP.t1 a_5484_3200.t5 VDD.t7 VDD.t6 pfet_03v3 ad=2.08p pd=8.52u as=2.08p ps=8.52u w=8u l=0.28u
X4 OUTP.t3 a_5484_3200.t2 VSS.t9 VSS.t8 nfet_03v3 ad=2.64p pd=12.88u as=1.56p ps=6.52u w=6u l=0.28u
X5 a_n7796_3000.t3 a_n9316_3400.t4 VDD.t29 VDD.t28 pfet_03v3 ad=3.52p pd=16.88u as=2.08p ps=8.52u w=8u l=0.28u
X6 VSS.t3 a_n9244_3330.t2 a_n9316_3400.t1 VSS.t2 nfet_03v3 ad=0.88p pd=4.88u as=0.88p ps=4.88u w=2u l=0.28u
X7 VSS.t5 a_n7796_3000.t6 a_5484_3200.t0 VSS.t4 nfet_03v3 ad=1.76p pd=8.88u as=1.76p ps=8.88u w=4u l=0.28u
X8 VSS.t26 VBIAS.t1 a_n1172_n800.t1 VSS.t25 nfet_03v3 ad=3.12p pd=12.52u as=5.28p ps=24.88u w=12u l=0.28u
X9 a_n7796_3000.t0 a_n9316_3400.t2 VSS.t1 VSS.t0 nfet_03v3 ad=2.64p pd=12.88u as=1.56p ps=6.52u w=6u l=0.28u
X10 VSS.t24 a_n7796_3000.t5 OUTN.t3 VSS.t23 nfet_03v3 ad=1.56p pd=6.52u as=2.64p ps=12.88u w=6u l=0.28u
X11 VSS.t11 a_5484_3200.t3 OUTP.t4 VSS.t10 nfet_03v3 ad=1.56p pd=6.52u as=2.64p ps=12.88u w=6u l=0.28u
X12 VSS.t17 VSS.t14 VSS.t16 VSS.t15 nfet_03v3 ad=3.52p pd=16.88u as=0 ps=0 w=8u l=0.28u
X13 OUTN.t4 a_n7796_3000.t8 VDD.t31 VDD.t30 pfet_03v3 ad=2.08p pd=8.52u as=2.08p ps=8.52u w=8u l=0.28u
X14 VDD.t15 VDD.t12 VDD.t14 VDD.t13 pfet_03v3 ad=3.52p pd=16.88u as=0 ps=0 w=8u l=0.28u
X15 VSS.t21 VSS.t18 VSS.t20 VSS.t19 nfet_03v3 ad=3.52p pd=16.88u as=0 ps=0 w=8u l=0.28u
X16 VDD.t19 VDD.t16 VDD.t18 VDD.t17 pfet_03v3 ad=3.52p pd=16.88u as=0 ps=0 w=8u l=0.28u
X17 OUTN.t0 a_n7796_3000.t4 VSS.t13 VSS.t12 nfet_03v3 ad=2.64p pd=12.88u as=1.56p ps=6.52u w=6u l=0.28u
X18 a_n1172_n800.t0 IN.t0 a_n1316_n800.t2 VSS.t22 nfet_03v3 ad=3.52p pd=16.88u as=3.52p ps=16.88u w=8u l=0.28u
X19 VDD.t3 a_n1316_n800.t0 a_n1316_n800.t1 VDD.t2 pfet_03v3 ad=3.52p pd=16.88u as=3.52p ps=16.88u w=8u l=0.28u
X20 a_n1172_n800.t3 REF.t0 a_n9244_3330.t1 VSS.t29 nfet_03v3 ad=3.52p pd=16.88u as=3.52p ps=16.88u w=8u l=0.28u
X21 VDD.t11 a_n1316_n800.t3 a_n9244_3330.t0 VDD.t10 pfet_03v3 ad=3.52p pd=16.88u as=3.52p ps=16.88u w=8u l=0.28u
X22 VDD.t9 a_5484_3200.t6 OUTP.t2 VDD.t8 pfet_03v3 ad=2.08p pd=8.52u as=3.52p ps=16.88u w=8u l=0.28u
X23 VDD.t25 a_n9244_3330.t3 a_n9316_3400.t0 VDD.t24 pfet_03v3 ad=1.76p pd=8.88u as=1.76p ps=8.88u w=4u l=0.28u
X24 VDD.t27 a_n7796_3000.t10 a_5484_3200.t1 VDD.t26 pfet_03v3 ad=3.52p pd=16.88u as=3.52p ps=16.88u w=8u l=0.28u
X25 VDD.t1 a_5484_3200.t4 OUTP.t0 VDD.t0 pfet_03v3 ad=3.52p pd=16.88u as=2.08p ps=8.52u w=8u l=0.28u
X26 VDD.t5 a_n9316_3400.t5 a_n7796_3000.t1 VDD.t4 pfet_03v3 ad=2.08p pd=8.52u as=3.52p ps=16.88u w=8u l=0.28u
X27 VDD.t23 a_n7796_3000.t9 OUTN.t2 VDD.t22 pfet_03v3 ad=2.08p pd=8.52u as=3.52p ps=16.88u w=8u l=0.28u
R0 VBIAS.n0 VBIAS.t0 165.774
R1 VBIAS.n0 VBIAS.t1 165.745
R2 VBIAS VBIAS.n0 36.5744
R3 REF REF.t0 162.293
R4 IN IN.t0 160.65
R5 OUTP.n3 OUTP.n1 12.2483
R6 OUTP OUTP.n3 10.2922
R7 OUTP.n2 OUTP.t3 5.80116
R8 OUTP.n2 OUTP.t4 5.61169
R9 OUTP.n1 OUTP.t2 5.59554
R10 OUTP.n1 OUTP.n0 5.46277
R11 OUTP.n3 OUTP.n2 4.77441
R12 OUTP.n0 OUTP.t0 0.228
R13 OUTP.n0 OUTP.t1 0.228
R14 OUTN OUTN.n3 13.0705
R15 OUTN.n3 OUTN.n1 12.5222
R16 OUTN.n2 OUTN.t0 5.80116
R17 OUTN.n2 OUTN.t3 5.61169
R18 OUTN.n1 OUTN.t2 5.59554
R19 OUTN.n1 OUTN.n0 5.46277
R20 OUTN.n3 OUTN.n2 4.5005
R21 OUTN.n0 OUTN.t1 0.228
R22 OUTN.n0 OUTN.t4 0.228
R23 VDD.n45 VDD.n44 266.668
R24 VDD.t26 VDD.n31 244.445
R25 VDD.t20 VDD.n30 226.667
R26 VDD.t13 VDD.n42 200
R27 VDD.t2 VDD.n41 200
R28 VDD.n32 VDD.t10 200
R29 VDD.n33 VDD.t17 200
R30 VDD.n54 VDD.t24 177.779
R31 VDD.t4 VDD.n43 146.667
R32 VDD.n7 VDD.t16 136.986
R33 VDD.n12 VDD.t12 136.986
R34 VDD.n44 VDD.t28 102.222
R35 VDD.n53 VDD.n18 94.5005
R36 VDD.n23 VDD.n18 94.5005
R37 VDD.n46 VDD.n23 94.5005
R38 VDD.n46 VDD.n22 94.5005
R39 VDD.n40 VDD.n22 94.5005
R40 VDD.n40 VDD.n24 94.5005
R41 VDD.n34 VDD.n24 94.5005
R42 VDD.n34 VDD.n28 94.5005
R43 VDD.n29 VDD.n28 94.5005
R44 VDD.n54 VDD.n53 72.9672
R45 VDD.n45 VDD.t13 66.6672
R46 VDD.n42 VDD.t2 66.6672
R47 VDD.n41 VDD.t10 66.6672
R48 VDD.t17 VDD.n32 66.6672
R49 VDD.n55 VDD.n54 26.4219
R50 VDD.n43 VDD.t24 22.2227
R51 VDD.n33 VDD.t26 22.2227
R52 VDD.n10 VDD.t11 20.2725
R53 VDD.n11 VDD.t3 20.1778
R54 VDD.n6 VDD.t27 18.316
R55 VDD.n16 VDD.n15 18.1359
R56 VDD.n17 VDD.t25 18.0802
R57 VDD.n52 VDD.n0 18.0005
R58 VDD.n51 VDD.n50 18.0005
R59 VDD.n49 VDD.n19 18.0005
R60 VDD.n48 VDD.n47 18.0005
R61 VDD.n21 VDD.n20 18.0005
R62 VDD.n39 VDD.n38 18.0005
R63 VDD.n37 VDD.n25 18.0005
R64 VDD.n36 VDD.n35 18.0005
R65 VDD.t28 VDD.t4 17.7783
R66 VDD.t22 VDD.t30 17.7783
R67 VDD.t30 VDD.t20 17.7783
R68 VDD.t8 VDD.t6 17.7783
R69 VDD.t6 VDD.t0 17.7783
R70 VDD.n5 VDD.n2 14.1183
R71 VDD.n5 VDD.n4 12.6973
R72 VDD.n8 VDD.t18 10.1192
R73 VDD.n13 VDD.t14 10.1192
R74 VDD.n7 VDD.t19 10.0719
R75 VDD.n12 VDD.t15 10.0719
R76 VDD.n36 VDD.n26 9.42313
R77 VDD.n9 VDD.n8 8.57007
R78 VDD.n14 VDD.n13 8.57007
R79 VDD.n29 VDD.n26 6.96266
R80 VDD.n53 VDD.n52 6.3005
R81 VDD.n43 VDD.n18 6.3005
R82 VDD.n51 VDD.n18 6.3005
R83 VDD.n44 VDD.n23 6.3005
R84 VDD.n23 VDD.n19 6.3005
R85 VDD.n46 VDD.n45 6.3005
R86 VDD.n47 VDD.n46 6.3005
R87 VDD.n42 VDD.n22 6.3005
R88 VDD.n22 VDD.n21 6.3005
R89 VDD.n41 VDD.n40 6.3005
R90 VDD.n40 VDD.n39 6.3005
R91 VDD.n32 VDD.n24 6.3005
R92 VDD.n25 VDD.n24 6.3005
R93 VDD.n34 VDD.n33 6.3005
R94 VDD.n35 VDD.n34 6.3005
R95 VDD.n31 VDD.n28 6.3005
R96 VDD.n28 VDD.n27 6.3005
R97 VDD.n30 VDD.n29 6.3005
R98 VDD.n2 VDD.t1 5.73764
R99 VDD.n4 VDD.t21 5.73764
R100 VDD.n2 VDD.n1 5.32067
R101 VDD.n4 VDD.n3 5.32067
R102 VDD.n56 VDD.n55 5.21103
R103 VDD.n31 VDD.t22 4.44494
R104 VDD.n30 VDD.t8 4.44494
R105 VDD.n11 VDD.n10 2.13208
R106 VDD.n16 VDD.n14 1.94261
R107 VDD.n17 VDD.n16 1.65839
R108 VDD.n9 VDD.n6 1.61103
R109 VDD.n52 VDD.n51 1.3505
R110 VDD.n51 VDD.n19 1.3505
R111 VDD.n47 VDD.n19 1.3505
R112 VDD.n47 VDD.n21 1.3505
R113 VDD.n39 VDD.n21 1.3505
R114 VDD.n39 VDD.n25 1.3505
R115 VDD.n35 VDD.n25 1.3505
R116 VDD.n35 VDD.n27 1.3505
R117 VDD.n8 VDD.n7 1.25267
R118 VDD.n13 VDD.n12 1.25267
R119 VDD.n14 VDD.n11 1.13734
R120 VDD.n10 VDD.n9 0.995237
R121 VDD.n55 VDD.n17 0.687342
R122 VDD.n27 VDD.n26 0.641316
R123 VDD.n50 VDD.n0 0.6005
R124 VDD.n50 VDD.n49 0.6005
R125 VDD.n49 VDD.n48 0.6005
R126 VDD.n48 VDD.n20 0.6005
R127 VDD.n38 VDD.n20 0.6005
R128 VDD.n38 VDD.n37 0.6005
R129 VDD.n37 VDD.n36 0.6005
R130 VDD.n6 VDD.n5 0.592605
R131 VDD.n56 VDD.n0 0.309974
R132 VDD.n1 VDD.t9 0.228
R133 VDD.n1 VDD.t7 0.228
R134 VDD.n3 VDD.t23 0.228
R135 VDD.n3 VDD.t31 0.228
R136 VDD.n15 VDD.t5 0.228
R137 VDD.n15 VDD.t29 0.228
R138 VDD VDD.n56 0.0205
R139 VSS.n63 VSS.n11 541.668
R140 VSS.n44 VSS.t4 496.529
R141 VSS.n38 VSS.t12 478.473
R142 VSS.t8 VSS.n37 415.279
R143 VSS.n57 VSS.t15 406.25
R144 VSS.n50 VSS.t29 406.25
R145 VSS.n43 VSS.t19 406.25
R146 VSS.n82 VSS.t2 361.111
R147 VSS.n64 VSS.t6 297.918
R148 VSS.t25 VSS.t22 252.779
R149 VSS.n81 VSS.n2 207.639
R150 VSS.t0 VSS.n63 207.639
R151 VSS.n36 VSS.n22 138.25
R152 VSS.n92 VSS.t18 136.776
R153 VSS.n87 VSS.t14 136.776
R154 VSS.n82 VSS.n81 135.417
R155 VSS.t15 VSS.n11 135.417
R156 VSS.n57 VSS.t22 135.417
R157 VSS.t29 VSS.n19 135.417
R158 VSS.n50 VSS.t19 135.417
R159 VSS.n39 VSS.n23 129.5
R160 VSS.n19 VSS.t27 117.362
R161 VSS.n28 VSS.n23 105.001
R162 VSS.n32 VSS.n31 105.001
R163 VSS.n36 VSS.n26 105.001
R164 VSS.n65 VSS.n1 105.001
R165 VSS.n65 VSS.n10 105.001
R166 VSS.n16 VSS.n10 105.001
R167 VSS.n56 VSS.n16 105.001
R168 VSS.n56 VSS.n15 105.001
R169 VSS.n51 VSS.n15 105.001
R170 VSS.n51 VSS.n18 105.001
R171 VSS.n42 VSS.n18 105.001
R172 VSS.n42 VSS.n39 105.001
R173 VSS.n73 VSS.n8 105.001
R174 VSS.n76 VSS.n75 105.001
R175 VSS.n80 VSS.n3 105.001
R176 VSS.n62 VSS.n3 105.001
R177 VSS.n62 VSS.n12 105.001
R178 VSS.n58 VSS.n12 105.001
R179 VSS.n58 VSS.n14 105.001
R180 VSS.n49 VSS.n14 105.001
R181 VSS.n49 VSS.n20 105.001
R182 VSS.n45 VSS.n20 105.001
R183 VSS.n45 VSS.n22 105.001
R184 VSS.n80 VSS.n4 85.7505
R185 VSS.n69 VSS.n1 77.0005
R186 VSS.n64 VSS.t2 45.1394
R187 VSS.t4 VSS.n43 45.1394
R188 VSS.t6 VSS.t0 36.1116
R189 VSS.t27 VSS.t25 36.1116
R190 VSS.t12 VSS.t23 36.1116
R191 VSS.t10 VSS.t8 36.1116
R192 VSS.n44 VSS.t23 27.0838
R193 VSS.n38 VSS.t10 27.0838
R194 VSS.n83 VSS.t3 26.0913
R195 VSS.n83 VSS.n82 25.7462
R196 VSS.n94 VSS.t5 24.8769
R197 VSS.n98 VSS.n97 24.3427
R198 VSS.n96 VSS.n95 24.3427
R199 VSS.n85 VSS.n84 24.1769
R200 VSS.n99 VSS.n0 18.3305
R201 VSS.n90 VSS.n89 17.0328
R202 VSS.n91 VSS.t21 11.3897
R203 VSS.n86 VSS.t17 11.3897
R204 VSS.n93 VSS.n92 10.2331
R205 VSS.n88 VSS.n87 10.2331
R206 VSS.n91 VSS.t20 10.2322
R207 VSS.n86 VSS.t16 10.2322
R208 VSS.n99 VSS.n98 5.70839
R209 VSS.n39 VSS.n38 5.2005
R210 VSS.n40 VSS.n39 5.2005
R211 VSS.n44 VSS.n42 5.2005
R212 VSS.n42 VSS.n41 5.2005
R213 VSS.n43 VSS.n18 5.2005
R214 VSS.n18 VSS.n17 5.2005
R215 VSS.n51 VSS.n50 5.2005
R216 VSS.n52 VSS.n51 5.2005
R217 VSS.n19 VSS.n15 5.2005
R218 VSS.n53 VSS.n15 5.2005
R219 VSS.n57 VSS.n56 5.2005
R220 VSS.n56 VSS.n55 5.2005
R221 VSS.n16 VSS.n11 5.2005
R222 VSS.n54 VSS.n16 5.2005
R223 VSS.n63 VSS.n10 5.2005
R224 VSS.n10 VSS.n9 5.2005
R225 VSS.n65 VSS.n64 5.2005
R226 VSS.n66 VSS.n65 5.2005
R227 VSS.n81 VSS.n1 5.2005
R228 VSS.n67 VSS.n1 5.2005
R229 VSS.n78 VSS.n4 5.2005
R230 VSS.n77 VSS.n76 5.2005
R231 VSS.n75 VSS.n6 5.2005
R232 VSS.n73 VSS.n72 5.2005
R233 VSS.n71 VSS.n8 5.2005
R234 VSS.n70 VSS.n69 5.2005
R235 VSS.n81 VSS.n80 5.2005
R236 VSS.n80 VSS.n79 5.2005
R237 VSS.n64 VSS.n3 5.2005
R238 VSS.n5 VSS.n3 5.2005
R239 VSS.n63 VSS.n62 5.2005
R240 VSS.n62 VSS.n61 5.2005
R241 VSS.n12 VSS.n11 5.2005
R242 VSS.n60 VSS.n12 5.2005
R243 VSS.n58 VSS.n57 5.2005
R244 VSS.n59 VSS.n58 5.2005
R245 VSS.n19 VSS.n14 5.2005
R246 VSS.n14 VSS.n13 5.2005
R247 VSS.n50 VSS.n49 5.2005
R248 VSS.n49 VSS.n48 5.2005
R249 VSS.n43 VSS.n20 5.2005
R250 VSS.n47 VSS.n20 5.2005
R251 VSS.n45 VSS.n44 5.2005
R252 VSS.n46 VSS.n45 5.2005
R253 VSS.n38 VSS.n22 5.2005
R254 VSS.n22 VSS.n21 5.2005
R255 VSS.n37 VSS.n23 5.2005
R256 VSS.n27 VSS.n23 5.2005
R257 VSS.n29 VSS.n28 5.2005
R258 VSS.n31 VSS.n30 5.2005
R259 VSS.n33 VSS.n32 5.2005
R260 VSS.n34 VSS.n26 5.2005
R261 VSS.n37 VSS.n36 5.2005
R262 VSS.n36 VSS.n35 5.2005
R263 VSS.n7 VSS.n4 4.73237
R264 VSS.n75 VSS.n74 4.73237
R265 VSS.n68 VSS.n8 4.73237
R266 VSS.n28 VSS.n25 4.73237
R267 VSS.n32 VSS.n24 4.73237
R268 VSS.n31 VSS.n25 4.73237
R269 VSS.n26 VSS.n24 4.73237
R270 VSS.n69 VSS.n68 4.73237
R271 VSS.n74 VSS.n73 4.73237
R272 VSS.n76 VSS.n7 4.73237
R273 VSS.n90 VSS.n88 2.55839
R274 VSS.n88 VSS.n85 2.17945
R275 VSS.n35 VSS.n21 1.778
R276 VSS.n93 VSS.n90 1.70576
R277 VSS.n98 VSS.n96 1.42155
R278 VSS.n94 VSS.n93 1.37418
R279 VSS.n67 VSS.n66 1.3505
R280 VSS.n66 VSS.n9 1.3505
R281 VSS.n54 VSS.n9 1.3505
R282 VSS.n55 VSS.n54 1.3505
R283 VSS.n55 VSS.n53 1.3505
R284 VSS.n53 VSS.n52 1.3505
R285 VSS.n52 VSS.n17 1.3505
R286 VSS.n41 VSS.n17 1.3505
R287 VSS.n41 VSS.n40 1.3505
R288 VSS.n71 VSS.n70 1.3505
R289 VSS.n72 VSS.n71 1.3505
R290 VSS.n72 VSS.n6 1.3505
R291 VSS.n77 VSS.n6 1.3505
R292 VSS.n78 VSS.n77 1.3505
R293 VSS.n79 VSS.n5 1.3505
R294 VSS.n61 VSS.n5 1.3505
R295 VSS.n61 VSS.n60 1.3505
R296 VSS.n60 VSS.n59 1.3505
R297 VSS.n59 VSS.n13 1.3505
R298 VSS.n48 VSS.n13 1.3505
R299 VSS.n48 VSS.n47 1.3505
R300 VSS.n47 VSS.n46 1.3505
R301 VSS.n46 VSS.n21 1.3505
R302 VSS.n29 VSS.n27 1.3505
R303 VSS.n30 VSS.n29 1.3505
R304 VSS.n33 VSS.n30 1.3505
R305 VSS.n34 VSS.n33 1.3505
R306 VSS.n35 VSS.n34 1.3505
R307 VSS.n40 VSS.n0 1.193
R308 VSS.n79 VSS.n78 1.103
R309 VSS.n96 VSS.n94 1.06629
R310 VSS.n70 VSS.n67 0.9905
R311 VSS.n85 VSS.n83 0.947868
R312 VSS.n27 VSS.n0 0.473
R313 VSS.n92 VSS.n91 0.293978
R314 VSS.n87 VSS.n86 0.293978
R315 VSS.n97 VSS.t11 0.2735
R316 VSS.n97 VSS.t9 0.2735
R317 VSS.n95 VSS.t24 0.2735
R318 VSS.n95 VSS.t13 0.2735
R319 VSS.n84 VSS.t7 0.2735
R320 VSS.n84 VSS.t1 0.2735
R321 VSS.n7 VSS.n2 0.235315
R322 VSS.n74 VSS.n2 0.235315
R323 VSS.n68 VSS.n2 0.235315
R324 VSS.n37 VSS.n25 0.235315
R325 VSS.n37 VSS.n24 0.235315
R326 VSS.n89 VSS.t26 0.137
R327 VSS.n89 VSS.t28 0.137
R328 VSS VSS.n99 0.0205
R329 a_n1172_n800.n0 a_n1172_n800.t3 24.5571
R330 a_n1172_n800.n0 a_n1172_n800.t0 12.0158
R331 a_n1172_n800.t2 a_n1172_n800.n1 5.91419
R332 a_n1172_n800.n1 a_n1172_n800.t1 5.72471
R333 a_n1172_n800.n1 a_n1172_n800.n0 5.02155
R334 a_n1316_n800.n0 a_n1316_n800.t3 162.118
R335 a_n1316_n800.n1 a_n1316_n800.t0 136.776
R336 a_n1316_n800.t1 a_n1316_n800.n1 11.6412
R337 a_n1316_n800.n0 a_n1316_n800.t2 10.1375
R338 a_n1316_n800.n1 a_n1316_n800.n0 7.84615
R339 a_n9244_3330.n0 a_n9244_3330.t3 92.4439
R340 a_n9244_3330.n0 a_n9244_3330.t2 58.7421
R341 a_n9244_3330.n1 a_n9244_3330.n0 19.8788
R342 a_n9244_3330.t0 a_n9244_3330.n1 18.2347
R343 a_n9244_3330.n1 a_n9244_3330.t1 11.3897
R344 a_5484_3200.n0 a_5484_3200.t4 113.632
R345 a_5484_3200.n2 a_5484_3200.t6 109.174
R346 a_5484_3200.n1 a_5484_3200.t5 109.174
R347 a_5484_3200.n4 a_5484_3200.t2 87.5599
R348 a_5484_3200.n4 a_5484_3200.t3 87.5312
R349 a_5484_3200.n3 a_5484_3200.n2 18.4942
R350 a_5484_3200.t1 a_5484_3200.n6 18.3129
R351 a_5484_3200.n5 a_5484_3200.n3 17.0794
R352 a_5484_3200.n5 a_5484_3200.n4 16.6044
R353 a_5484_3200.n6 a_5484_3200.n5 13.9505
R354 a_5484_3200.n2 a_5484_3200.n1 11.6805
R355 a_5484_3200.n6 a_5484_3200.t0 10.4377
R356 a_5484_3200.n3 a_5484_3200.n0 7.17687
R357 a_5484_3200.n1 a_5484_3200.n0 4.42851
R358 a_n7796_3000.n6 a_n7796_3000.t10 144.392
R359 a_n7796_3000.n0 a_n7796_3000.t9 113.632
R360 a_n7796_3000.n1 a_n7796_3000.t8 109.174
R361 a_n7796_3000.n2 a_n7796_3000.t7 109.174
R362 a_n7796_3000.n4 a_n7796_3000.t5 87.5599
R363 a_n7796_3000.n4 a_n7796_3000.t4 87.5312
R364 a_n7796_3000.n6 a_n7796_3000.t6 84.8135
R365 a_n7796_3000.n9 a_n7796_3000.n7 19.3505
R366 a_n7796_3000.n3 a_n7796_3000.n2 18.4942
R367 a_n7796_3000.n5 a_n7796_3000.n3 17.0989
R368 a_n7796_3000.n5 a_n7796_3000.n4 16.5849
R369 a_n7796_3000.n10 a_n7796_3000.n9 12.5222
R370 a_n7796_3000.n2 a_n7796_3000.n1 11.6805
R371 a_n7796_3000.n7 a_n7796_3000.n5 7.47441
R372 a_n7796_3000.n3 a_n7796_3000.n0 7.17687
R373 a_n7796_3000.n8 a_n7796_3000.t0 5.80116
R374 a_n7796_3000.n10 a_n7796_3000.t3 5.73764
R375 a_n7796_3000.n8 a_n7796_3000.t2 5.61169
R376 a_n7796_3000.t1 a_n7796_3000.n10 5.54817
R377 a_n7796_3000.n7 a_n7796_3000.n6 4.98963
R378 a_n7796_3000.n9 a_n7796_3000.n8 4.5005
R379 a_n7796_3000.n1 a_n7796_3000.n0 4.42851
R380 a_n9316_3400.n0 a_n9316_3400.t5 113.632
R381 a_n9316_3400.n0 a_n9316_3400.t4 113.603
R382 a_n9316_3400.n1 a_n9316_3400.t3 87.5599
R383 a_n9316_3400.n1 a_n9316_3400.t2 87.5312
R384 a_n9316_3400.n2 a_n9316_3400.n0 23.9153
R385 a_n9316_3400.t0 a_n9316_3400.n3 18.2696
R386 a_n9316_3400.n2 a_n9316_3400.n1 16.2849
R387 a_n9316_3400.n3 a_n9316_3400.n2 13.1288
R388 a_n9316_3400.n3 a_n9316_3400.t1 11.5544
C0 VBIAS IN 0.23252f
C1 OUTP VDD 5.23498f
C2 IN REF 2.51858f
C3 VDD OUTN 5.46611f
C4 OUTP OUTN 0.46913f
C5 VBIAS REF 2.54517f
C6 VBIAS VSS 5.26603f
C7 REF VSS 8.38255f
C8 IN VSS 7.34488f
C9 OUTP VSS 4.29259f
C10 OUTN VSS 5.2781f
C11 VDD VSS 0.69733p
C12 a_n9316_3400.n0 VSS 0.63055f
C13 a_n9316_3400.n1 VSS 0.27039f
C14 a_n9316_3400.n2 VSS 2.21748f
C15 a_n9316_3400.t1 VSS 0.25674f
C16 a_n9316_3400.n3 VSS 2.2291f
C17 a_n9316_3400.t0 VSS 0.95529f
C18 a_n7796_3000.t3 VSS 0.73547f
C19 a_n7796_3000.n0 VSS 0.08254f
C20 a_n7796_3000.n1 VSS 0.08847f
C21 a_n7796_3000.n2 VSS 0.08361f
C22 a_n7796_3000.n3 VSS 0.77157f
C23 a_n7796_3000.n4 VSS 0.32504f
C24 a_n7796_3000.n5 VSS 1.74153f
C25 a_n7796_3000.n6 VSS 2.2486f
C26 a_n7796_3000.n7 VSS 2.60485f
C27 a_n7796_3000.t0 VSS 0.54409f
C28 a_n7796_3000.t2 VSS 0.53962f
C29 a_n7796_3000.n8 VSS 0.27019f
C30 a_n7796_3000.n9 VSS 2.67686f
C31 a_n7796_3000.n10 VSS 0.87711f
C32 a_n7796_3000.t1 VSS 0.7308f
C33 a_5484_3200.n0 VSS 0.0938f
C34 a_5484_3200.n1 VSS 0.10054f
C35 a_5484_3200.n2 VSS 0.09502f
C36 a_5484_3200.n3 VSS 0.87504f
C37 a_5484_3200.n4 VSS 0.36962f
C38 a_5484_3200.n5 VSS 2.38391f
C39 a_5484_3200.t0 VSS 0.46883f
C40 a_5484_3200.n6 VSS 2.58536f
C41 a_5484_3200.t1 VSS 1.45454f
C42 a_n9244_3330.t1 VSS 1.28707f
C43 a_n9244_3330.n0 VSS 4.22143f
C44 a_n9244_3330.n1 VSS 3.76709f
C45 a_n9244_3330.t0 VSS 1.76054f
C46 a_n1316_n800.t2 VSS 1.07865f
C47 a_n1316_n800.n0 VSS 5.42995f
C48 a_n1316_n800.n1 VSS 1.73632f
C49 a_n1316_n800.t1 VSS 0.97176f
C50 a_n1172_n800.t0 VSS 1.01577f
C51 a_n1172_n800.t3 VSS 1.63038f
C52 a_n1172_n800.n0 VSS 1.42788f
C53 a_n1172_n800.t1 VSS 1.08514f
C54 a_n1172_n800.n1 VSS 0.61622f
C55 a_n1172_n800.t2 VSS 1.09021f
C56 VSS.t3 VSS 0.0598f
C57 VSS.t1 VSS 0.06998f
C58 VSS.t7 VSS 0.07f
C59 VSS.t28 VSS 0.10852f
C60 VSS.t26 VSS 0.10851f
C61 VSS.t5 VSS 0.06402f
C62 VSS.t13 VSS 0.06725f
C63 VSS.t24 VSS 0.06727f
C64 VSS.t9 VSS 0.07644f
C65 VSS.t11 VSS 0.07642f
C66 VDD.n0 VSS 0.04727f
C67 VDD.t1 VSS 0.13576f
C68 VDD.t7 VSS 0.10328f
C69 VDD.t9 VSS 0.10328f
C70 VDD.n1 VSS 0.02946f
C71 VDD.n2 VSS 0.06401f
C72 VDD.t21 VSS 0.12217f
C73 VDD.t31 VSS 0.09156f
C74 VDD.t23 VSS 0.09321f
C75 VDD.n3 VSS 0.02946f
C76 VDD.n4 VSS 0.04791f
C77 VDD.n5 VSS 0.14744f
C78 VDD.t27 VSS 0.19449f
C79 VDD.n6 VSS 0.07499f
C80 VDD.t19 VSS 0.04468f
C81 VDD.n7 VSS 0.02542f
C82 VDD.t18 VSS 0.04543f
C83 VDD.n8 VSS 0.0533f
C84 VDD.n9 VSS 0.05863f
C85 VDD.t11 VSS 0.41548f
C86 VDD.n10 VSS 0.10616f
C87 VDD.t3 VSS 0.18703f
C88 VDD.n11 VSS 0.10758f
C89 VDD.t15 VSS 0.04468f
C90 VDD.n12 VSS 0.02542f
C91 VDD.t14 VSS 0.04543f
C92 VDD.n13 VSS 0.0533f
C93 VDD.n14 VSS 0.06694f
C94 VDD.t29 VSS 0.09675f
C95 VDD.t5 VSS 0.09677f
C96 VDD.n15 VSS 0.0593f
C97 VDD.n16 VSS 0.09933f
C98 VDD.t25 VSS 0.17558f
C99 VDD.n17 VSS 0.07345f
C100 VDD.t24 VSS 1.10801f
C101 VDD.n18 VSS 0.05253f
C102 VDD.n19 VSS 0.05477f
C103 VDD.n20 VSS 0.05577f
C104 VDD.n21 VSS 0.05477f
C105 VDD.n22 VSS 0.05253f
C106 VDD.n23 VSS 0.05253f
C107 VDD.t10 VSS 1.47735f
C108 VDD.n24 VSS 0.05253f
C109 VDD.n25 VSS 0.05477f
C110 VDD.n26 VSS 0.07996f
C111 VDD.n27 VSS 0.05477f
C112 VDD.n28 VSS 0.05253f
C113 VDD.t0 VSS 2.61804f
C114 VDD.t6 VSS 0.19698f
C115 VDD.t8 VSS 0.12311f
C116 VDD.n29 VSS 0.08194f
C117 VDD.n30 VSS 1.28132f
C118 VDD.t20 VSS 1.36135f
C119 VDD.t30 VSS 0.19698f
C120 VDD.t22 VSS 0.12311f
C121 VDD.n31 VSS 1.37886f
C122 VDD.t26 VSS 1.47735f
C123 VDD.n32 VSS 1.47735f
C124 VDD.t17 VSS 1.48003f
C125 VDD.n33 VSS 1.2365f
C126 VDD.n34 VSS 0.05253f
C127 VDD.n35 VSS 0.05477f
C128 VDD.n36 VSS 0.17834f
C129 VDD.n37 VSS 0.05577f
C130 VDD.n38 VSS 0.05577f
C131 VDD.n39 VSS 0.05477f
C132 VDD.n40 VSS 0.05253f
C133 VDD.n41 VSS 1.48272f
C134 VDD.t2 VSS 1.48003f
C135 VDD.n42 VSS 1.47735f
C136 VDD.t13 VSS 1.47735f
C137 VDD.n43 VSS 0.94005f
C138 VDD.t4 VSS 0.9147f
C139 VDD.t28 VSS 0.66481f
C140 VDD.n44 VSS 2.04568f
C141 VDD.n45 VSS 1.85273f
C142 VDD.n46 VSS 0.05253f
C143 VDD.n47 VSS 0.05477f
C144 VDD.n48 VSS 0.05577f
C145 VDD.n49 VSS 0.05577f
C146 VDD.n50 VSS 0.05577f
C147 VDD.n51 VSS 0.05477f
C148 VDD.n52 VSS 0.05039f
C149 VDD.n53 VSS 1.73539f
C150 VDD.n54 VSS 1.5191f
C151 VDD.n55 VSS 0.04766f
C152 VDD.n56 VSS 0.02229f
C153 OUTN.t1 VSS 0.21331f
C154 OUTN.t4 VSS 0.21331f
C155 OUTN.n0 VSS 0.66308f
C156 OUTN.t2 VSS 0.89561f
C157 OUTN.n1 VSS 1.07891f
C158 OUTN.t0 VSS 0.66535f
C159 OUTN.t3 VSS 0.65971f
C160 OUTN.n2 VSS 0.34086f
C161 OUTN.n3 VSS 2.26068f
C162 OUTP.t0 VSS 0.23671f
C163 OUTP.t1 VSS 0.23484f
C164 OUTP.n0 VSS 0.71415f
C165 OUTP.t2 VSS 0.96792f
C166 OUTP.n1 VSS 1.12495f
C167 OUTP.t3 VSS 0.72062f
C168 OUTP.t4 VSS 0.71451f
C169 OUTP.n2 VSS 0.37088f
C170 OUTP.n3 VSS 2.03695f
C171 VBIAS.n0 VSS 1.00473f
.ends
