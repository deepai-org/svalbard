* PEX produced using /foss/tools/sak/sak-pex.sh with m=3 and s=1 (extresist threshold=0 mOhm, minres=1 mOhm, mindelay=0 ps)
* NGSPICE file created from reference_level_receiver_pex.ext - technology: gf180mcuD

.subckt reference_level_receiver_pex IN REF VBIAS VDD VSS OUTP OUTN
X0 VDD.t23 a_n7716_3000.t4 OUTN.t2 VDD.t22 pfet_03v3 ad=2.08p pd=8.52u as=3.52p ps=16.88u w=8u l=0.28u
X1 a_n1172_n800.t2 VBIAS.t0 VSS.t20 VSS.t19 nfet_03v3 ad=5.28p pd=24.88u as=3.12p ps=12.52u w=12u l=0.28u
X2 VSS.t3 a_n9244_3330.t2 a_n9316_3400.t1 VSS.t2 nfet_03v3 ad=0.88p pd=4.88u as=0.88p ps=4.88u w=2u l=0.28u
X3 VSS.t18 VBIAS.t1 a_n1172_n800.t1 VSS.t17 nfet_03v3 ad=3.12p pd=12.52u as=5.28p ps=24.88u w=12u l=0.28u
X4 VSS.t12 VSS.t9 VSS.t11 VSS.t10 nfet_03v3 ad=3.52p pd=16.88u as=0 ps=0 w=8u l=0.28u
X5 VDD.t15 VDD.t12 VDD.t14 VDD.t13 pfet_03v3 ad=3.52p pd=16.88u as=0 ps=0 w=8u l=0.28u
X6 VSS.t16 VSS.t13 VSS.t15 VSS.t14 nfet_03v3 ad=3.52p pd=16.88u as=0 ps=0 w=8u l=0.28u
X7 VDD.t19 VDD.t16 VDD.t18 VDD.t17 pfet_03v3 ad=3.52p pd=16.88u as=0 ps=0 w=8u l=0.28u
X8 a_n1172_n800.t0 IN.t0 a_n1316_n800.t2 VSS.t8 nfet_03v3 ad=3.52p pd=16.88u as=3.52p ps=16.88u w=8u l=0.28u
X9 VDD.t3 a_n1316_n800.t0 a_n1316_n800.t1 VDD.t2 pfet_03v3 ad=3.52p pd=16.88u as=3.52p ps=16.88u w=8u l=0.28u
X10 a_n1172_n800.t3 REF.t0 a_n9244_3330.t1 VSS.t21 nfet_03v3 ad=3.52p pd=16.88u as=3.52p ps=16.88u w=8u l=0.28u
X11 VDD.t1 a_n1316_n800.t3 a_n9244_3330.t0 VDD.t0 pfet_03v3 ad=3.52p pd=16.88u as=3.52p ps=16.88u w=8u l=0.28u
X12 VSS.t7 a_n9316_3400.t2 a_n7716_3000.t1 VSS.t6 nfet_03v3 ad=2.64p pd=12.88u as=2.64p ps=12.88u w=6u l=0.28u
X13 VDD.t21 a_n9244_3330.t3 a_n9316_3400.t0 VDD.t20 pfet_03v3 ad=1.76p pd=8.88u as=1.76p ps=8.88u w=4u l=0.28u
X14 OUTN.t0 a_n7716_3000.t3 VDD.t9 VDD.t8 pfet_03v3 ad=3.52p pd=16.88u as=2.08p ps=8.52u w=8u l=0.28u
X15 OUTP.t0 OUTN.t4 VDD.t7 VDD.t6 pfet_03v3 ad=3.52p pd=16.88u as=2.08p ps=8.52u w=8u l=0.28u
X16 VSS.t1 OUTN.t3 OUTP.t1 VSS.t0 nfet_03v3 ad=2.64p pd=12.88u as=2.64p ps=12.88u w=6u l=0.28u
X17 VDD.t11 a_n9316_3400.t3 a_n7716_3000.t0 VDD.t10 pfet_03v3 ad=5.28p pd=24.88u as=5.28p ps=24.88u w=12u l=0.28u
X18 VSS.t5 a_n7716_3000.t2 OUTN.t1 VSS.t4 nfet_03v3 ad=2.64p pd=12.88u as=2.64p ps=12.88u w=6u l=0.28u
X19 VDD.t5 OUTN.t5 OUTP.t2 VDD.t4 pfet_03v3 ad=2.08p pd=8.52u as=3.52p ps=16.88u w=8u l=0.28u
R0 VBIAS.n0 VBIAS.t0 165.774
R1 VBIAS.n0 VBIAS.t1 165.745
R2 VBIAS VBIAS.n0 36.5744
R3 REF REF.t0 162.293
R4 IN IN.t0 160.65
R5 OUTP OUTP.n1 13.0314
R6 OUTP.n1 OUTP.n0 13.0309
R7 OUTP.n1 OUTP.t1 10.433
R8 OUTP.n0 OUTP.t0 5.73764
R9 OUTP.n0 OUTP.t2 5.54817
R10 OUTN.n2 OUTN.t5 113.632
R11 OUTN.n2 OUTN.t4 113.603
R12 OUTN.n3 OUTN.t3 112.001
R13 OUTN.n3 OUTN.n2 23.5827
R14 OUTN.n1 OUTN.n0 12.5222
R15 OUTN.n1 OUTN.t1 10.1591
R16 OUTN OUTN.n4 8.37485
R17 OUTN.n4 OUTN.n1 6.59398
R18 OUTN.n0 OUTN.t0 5.73764
R19 OUTN.n0 OUTN.t2 5.54817
R20 OUTN.n4 OUTN.n3 4.5005
R21 VDD.n39 VDD.n38 266.668
R22 VDD.t13 VDD.n36 200
R23 VDD.t2 VDD.n35 200
R24 VDD.n26 VDD.t0 200
R25 VDD.n27 VDD.t17 200
R26 VDD.n48 VDD.t20 177.779
R27 VDD.t8 VDD.t4 160
R28 VDD.t10 VDD.n37 155.556
R29 VDD.n4 VDD.t16 136.986
R30 VDD.n9 VDD.t12 136.986
R31 VDD.n38 VDD.t10 111.112
R32 VDD.n47 VDD.n14 94.5005
R33 VDD.n19 VDD.n14 94.5005
R34 VDD.n40 VDD.n19 94.5005
R35 VDD.n40 VDD.n18 94.5005
R36 VDD.n34 VDD.n18 94.5005
R37 VDD.n34 VDD.n20 94.5005
R38 VDD.n28 VDD.n20 94.5005
R39 VDD.n28 VDD.n24 94.5005
R40 VDD.n25 VDD.n22 75.9777
R41 VDD.n48 VDD.n47 72.9672
R42 VDD.n39 VDD.t13 66.6672
R43 VDD.n36 VDD.t2 66.6672
R44 VDD.n35 VDD.t0 66.6672
R45 VDD.t17 VDD.n26 66.6672
R46 VDD.n27 VDD.t22 57.7783
R47 VDD.n49 VDD.n48 26.4219
R48 VDD.n37 VDD.t20 22.2227
R49 VDD.n7 VDD.t1 20.2725
R50 VDD.n8 VDD.t3 20.1778
R51 VDD.n12 VDD.t11 18.855
R52 VDD.n13 VDD.t21 18.0802
R53 VDD.n46 VDD.n0 18.0005
R54 VDD.n45 VDD.n44 18.0005
R55 VDD.n43 VDD.n15 18.0005
R56 VDD.n42 VDD.n41 18.0005
R57 VDD.n17 VDD.n16 18.0005
R58 VDD.n33 VDD.n32 18.0005
R59 VDD.n31 VDD.n21 18.0005
R60 VDD.n30 VDD.n29 18.0005
R61 VDD.t6 VDD.n25 17.9353
R62 VDD.t22 VDD.t8 17.7783
R63 VDD.t4 VDD.t6 17.7783
R64 VDD.n3 VDD.n1 11.0533
R65 VDD.n3 VDD.n2 10.318
R66 VDD.n5 VDD.t18 10.1192
R67 VDD.n10 VDD.t14 10.1192
R68 VDD.n4 VDD.t19 10.0719
R69 VDD.n9 VDD.t15 10.0719
R70 VDD.n30 VDD.n22 9.42313
R71 VDD.n6 VDD.n3 8.93048
R72 VDD.n6 VDD.n5 8.57007
R73 VDD.n11 VDD.n10 8.57007
R74 VDD.n47 VDD.n46 6.3005
R75 VDD.n37 VDD.n14 6.3005
R76 VDD.n45 VDD.n14 6.3005
R77 VDD.n38 VDD.n19 6.3005
R78 VDD.n19 VDD.n15 6.3005
R79 VDD.n40 VDD.n39 6.3005
R80 VDD.n41 VDD.n40 6.3005
R81 VDD.n36 VDD.n18 6.3005
R82 VDD.n18 VDD.n17 6.3005
R83 VDD.n35 VDD.n34 6.3005
R84 VDD.n34 VDD.n33 6.3005
R85 VDD.n26 VDD.n20 6.3005
R86 VDD.n21 VDD.n20 6.3005
R87 VDD.n28 VDD.n27 6.3005
R88 VDD.n29 VDD.n28 6.3005
R89 VDD.n24 VDD.n23 6.3005
R90 VDD.n50 VDD.n49 5.21103
R91 VDD.n8 VDD.n7 2.13208
R92 VDD.n12 VDD.n11 1.94261
R93 VDD.n13 VDD.n12 1.65839
R94 VDD.n25 VDD.n24 1.59384
R95 VDD.n46 VDD.n45 1.3505
R96 VDD.n45 VDD.n15 1.3505
R97 VDD.n41 VDD.n15 1.3505
R98 VDD.n41 VDD.n17 1.3505
R99 VDD.n33 VDD.n17 1.3505
R100 VDD.n33 VDD.n21 1.3505
R101 VDD.n29 VDD.n21 1.3505
R102 VDD.n29 VDD.n23 1.3505
R103 VDD.n5 VDD.n4 1.25267
R104 VDD.n10 VDD.n9 1.25267
R105 VDD.n11 VDD.n8 1.13734
R106 VDD.n7 VDD.n6 0.995237
R107 VDD.n49 VDD.n13 0.687342
R108 VDD.n23 VDD.n22 0.641316
R109 VDD.n44 VDD.n0 0.6005
R110 VDD.n44 VDD.n43 0.6005
R111 VDD.n43 VDD.n42 0.6005
R112 VDD.n42 VDD.n16 0.6005
R113 VDD.n32 VDD.n16 0.6005
R114 VDD.n32 VDD.n31 0.6005
R115 VDD.n31 VDD.n30 0.6005
R116 VDD.n50 VDD.n0 0.309974
R117 VDD.n1 VDD.t23 0.228
R118 VDD.n1 VDD.t9 0.228
R119 VDD.n2 VDD.t5 0.228
R120 VDD.n2 VDD.t7 0.228
R121 VDD VDD.n50 0.0205
R122 VSS.n63 VSS.n11 541.668
R123 VSS.n44 VSS.n23 541.668
R124 VSS.n37 VSS.n23 478.473
R125 VSS.n57 VSS.t10 406.25
R126 VSS.n50 VSS.t21 406.25
R127 VSS.n43 VSS.t14 406.25
R128 VSS.n82 VSS.t2 361.111
R129 VSS.t0 VSS.t4 361.111
R130 VSS.n64 VSS.t6 315.973
R131 VSS.t17 VSS.t8 252.779
R132 VSS.t6 VSS.n63 225.695
R133 VSS.n81 VSS.n2 207.639
R134 VSS.n36 VSS.n22 138.25
R135 VSS.n91 VSS.t13 136.776
R136 VSS.n86 VSS.t9 136.776
R137 VSS.n82 VSS.n81 135.417
R138 VSS.t10 VSS.n11 135.417
R139 VSS.n57 VSS.t8 135.417
R140 VSS.t21 VSS.n19 135.417
R141 VSS.n50 VSS.t14 135.417
R142 VSS.t4 VSS.n43 135.417
R143 VSS.n39 VSS.n38 129.5
R144 VSS.n19 VSS.t19 117.362
R145 VSS.n38 VSS.n24 105.001
R146 VSS.n32 VSS.n31 105.001
R147 VSS.n36 VSS.n28 105.001
R148 VSS.n65 VSS.n1 105.001
R149 VSS.n65 VSS.n10 105.001
R150 VSS.n16 VSS.n10 105.001
R151 VSS.n56 VSS.n16 105.001
R152 VSS.n56 VSS.n15 105.001
R153 VSS.n51 VSS.n15 105.001
R154 VSS.n51 VSS.n18 105.001
R155 VSS.n42 VSS.n18 105.001
R156 VSS.n42 VSS.n39 105.001
R157 VSS.n73 VSS.n8 105.001
R158 VSS.n76 VSS.n75 105.001
R159 VSS.n80 VSS.n3 105.001
R160 VSS.n62 VSS.n3 105.001
R161 VSS.n62 VSS.n12 105.001
R162 VSS.n58 VSS.n12 105.001
R163 VSS.n58 VSS.n14 105.001
R164 VSS.n49 VSS.n14 105.001
R165 VSS.n49 VSS.n20 105.001
R166 VSS.n45 VSS.n20 105.001
R167 VSS.n45 VSS.n22 105.001
R168 VSS.n80 VSS.n4 85.7505
R169 VSS.n69 VSS.n1 77.0005
R170 VSS.n64 VSS.t2 45.1394
R171 VSS.n44 VSS.t0 45.1394
R172 VSS.t19 VSS.t17 36.1116
R173 VSS.n83 VSS.t3 26.0913
R174 VSS.n83 VSS.n82 25.7462
R175 VSS.n94 VSS.t1 24.4025
R176 VSS.n93 VSS.t5 24.4025
R177 VSS.n84 VSS.t7 24.4025
R178 VSS.n95 VSS.n0 18.3305
R179 VSS.n89 VSS.n88 17.0328
R180 VSS.n90 VSS.t16 11.3897
R181 VSS.n85 VSS.t12 11.3897
R182 VSS.n92 VSS.n91 10.2331
R183 VSS.n87 VSS.n86 10.2331
R184 VSS.n90 VSS.t15 10.2322
R185 VSS.n85 VSS.t11 10.2322
R186 VSS.n95 VSS.n94 7.01103
R187 VSS.n39 VSS.n23 5.2005
R188 VSS.n40 VSS.n39 5.2005
R189 VSS.n44 VSS.n42 5.2005
R190 VSS.n42 VSS.n41 5.2005
R191 VSS.n43 VSS.n18 5.2005
R192 VSS.n18 VSS.n17 5.2005
R193 VSS.n51 VSS.n50 5.2005
R194 VSS.n52 VSS.n51 5.2005
R195 VSS.n19 VSS.n15 5.2005
R196 VSS.n53 VSS.n15 5.2005
R197 VSS.n57 VSS.n56 5.2005
R198 VSS.n56 VSS.n55 5.2005
R199 VSS.n16 VSS.n11 5.2005
R200 VSS.n54 VSS.n16 5.2005
R201 VSS.n63 VSS.n10 5.2005
R202 VSS.n10 VSS.n9 5.2005
R203 VSS.n65 VSS.n64 5.2005
R204 VSS.n66 VSS.n65 5.2005
R205 VSS.n81 VSS.n1 5.2005
R206 VSS.n67 VSS.n1 5.2005
R207 VSS.n78 VSS.n4 5.2005
R208 VSS.n77 VSS.n76 5.2005
R209 VSS.n75 VSS.n6 5.2005
R210 VSS.n73 VSS.n72 5.2005
R211 VSS.n71 VSS.n8 5.2005
R212 VSS.n70 VSS.n69 5.2005
R213 VSS.n81 VSS.n80 5.2005
R214 VSS.n80 VSS.n79 5.2005
R215 VSS.n64 VSS.n3 5.2005
R216 VSS.n5 VSS.n3 5.2005
R217 VSS.n63 VSS.n62 5.2005
R218 VSS.n62 VSS.n61 5.2005
R219 VSS.n12 VSS.n11 5.2005
R220 VSS.n60 VSS.n12 5.2005
R221 VSS.n58 VSS.n57 5.2005
R222 VSS.n59 VSS.n58 5.2005
R223 VSS.n19 VSS.n14 5.2005
R224 VSS.n14 VSS.n13 5.2005
R225 VSS.n50 VSS.n49 5.2005
R226 VSS.n49 VSS.n48 5.2005
R227 VSS.n43 VSS.n20 5.2005
R228 VSS.n47 VSS.n20 5.2005
R229 VSS.n45 VSS.n44 5.2005
R230 VSS.n46 VSS.n45 5.2005
R231 VSS.n23 VSS.n22 5.2005
R232 VSS.n22 VSS.n21 5.2005
R233 VSS.n38 VSS.n37 5.2005
R234 VSS.n38 VSS.n25 5.2005
R235 VSS.n29 VSS.n24 5.2005
R236 VSS.n31 VSS.n30 5.2005
R237 VSS.n33 VSS.n32 5.2005
R238 VSS.n34 VSS.n28 5.2005
R239 VSS.n37 VSS.n36 5.2005
R240 VSS.n36 VSS.n35 5.2005
R241 VSS.n7 VSS.n4 4.73237
R242 VSS.n75 VSS.n74 4.73237
R243 VSS.n68 VSS.n8 4.73237
R244 VSS.n27 VSS.n24 4.73237
R245 VSS.n32 VSS.n26 4.73237
R246 VSS.n31 VSS.n27 4.73237
R247 VSS.n28 VSS.n26 4.73237
R248 VSS.n69 VSS.n68 4.73237
R249 VSS.n74 VSS.n73 4.73237
R250 VSS.n76 VSS.n7 4.73237
R251 VSS.n89 VSS.n87 2.55839
R252 VSS.n87 VSS.n84 2.17945
R253 VSS.n35 VSS.n21 1.778
R254 VSS.n92 VSS.n89 1.70576
R255 VSS.n93 VSS.n92 1.61103
R256 VSS.n67 VSS.n66 1.3505
R257 VSS.n66 VSS.n9 1.3505
R258 VSS.n54 VSS.n9 1.3505
R259 VSS.n55 VSS.n54 1.3505
R260 VSS.n55 VSS.n53 1.3505
R261 VSS.n53 VSS.n52 1.3505
R262 VSS.n52 VSS.n17 1.3505
R263 VSS.n41 VSS.n17 1.3505
R264 VSS.n41 VSS.n40 1.3505
R265 VSS.n71 VSS.n70 1.3505
R266 VSS.n72 VSS.n71 1.3505
R267 VSS.n72 VSS.n6 1.3505
R268 VSS.n77 VSS.n6 1.3505
R269 VSS.n78 VSS.n77 1.3505
R270 VSS.n79 VSS.n5 1.3505
R271 VSS.n61 VSS.n5 1.3505
R272 VSS.n61 VSS.n60 1.3505
R273 VSS.n60 VSS.n59 1.3505
R274 VSS.n59 VSS.n13 1.3505
R275 VSS.n48 VSS.n13 1.3505
R276 VSS.n48 VSS.n47 1.3505
R277 VSS.n47 VSS.n46 1.3505
R278 VSS.n46 VSS.n21 1.3505
R279 VSS.n29 VSS.n25 1.3505
R280 VSS.n30 VSS.n29 1.3505
R281 VSS.n33 VSS.n30 1.3505
R282 VSS.n34 VSS.n33 1.3505
R283 VSS.n35 VSS.n34 1.3505
R284 VSS.n40 VSS.n0 1.193
R285 VSS.n79 VSS.n78 1.103
R286 VSS.n70 VSS.n67 0.9905
R287 VSS.n84 VSS.n83 0.947868
R288 VSS.n94 VSS.n93 0.947868
R289 VSS.n25 VSS.n0 0.473
R290 VSS.n91 VSS.n90 0.293978
R291 VSS.n86 VSS.n85 0.293978
R292 VSS.n7 VSS.n2 0.235315
R293 VSS.n74 VSS.n2 0.235315
R294 VSS.n68 VSS.n2 0.235315
R295 VSS.n37 VSS.n27 0.235315
R296 VSS.n37 VSS.n26 0.235315
R297 VSS.n88 VSS.t18 0.137
R298 VSS.n88 VSS.t20 0.137
R299 VSS VSS.n95 0.0205
R300 a_n1172_n800.n0 a_n1172_n800.t3 24.5571
R301 a_n1172_n800.n0 a_n1172_n800.t0 12.0158
R302 a_n1172_n800.t2 a_n1172_n800.n1 5.91419
R303 a_n1172_n800.n1 a_n1172_n800.t1 5.72471
R304 a_n1172_n800.n1 a_n1172_n800.n0 5.02155
R305 a_n1316_n800.n0 a_n1316_n800.t3 162.118
R306 a_n1316_n800.n1 a_n1316_n800.t0 136.776
R307 a_n1316_n800.t1 a_n1316_n800.n1 11.6412
R308 a_n1316_n800.n0 a_n1316_n800.t2 10.1375
R309 a_n1316_n800.n1 a_n1316_n800.n0 7.84615
R310 a_n9244_3330.n0 a_n9244_3330.t3 92.4439
R311 a_n9244_3330.n0 a_n9244_3330.t2 58.7421
R312 a_n9244_3330.n1 a_n9244_3330.n0 19.8788
R313 a_n9244_3330.t0 a_n9244_3330.n1 18.2347
R314 a_n9244_3330.n1 a_n9244_3330.t1 11.3897
R315 a_n7716_3000.n0 a_n7716_3000.t4 113.632
R316 a_n7716_3000.n0 a_n7716_3000.t3 113.603
R317 a_n7716_3000.n1 a_n7716_3000.t2 110.885
R318 a_n7716_3000.n2 a_n7716_3000.n1 24.5353
R319 a_n7716_3000.n1 a_n7716_3000.n0 23.9153
R320 a_n7716_3000.t0 a_n7716_3000.n2 18.6563
R321 a_n7716_3000.n2 a_n7716_3000.t1 10.1591
R322 a_n9316_3400.n0 a_n9316_3400.t3 196.339
R323 a_n9316_3400.n0 a_n9316_3400.t2 110.885
R324 a_n9316_3400.t0 a_n9316_3400.n1 18.2696
R325 a_n9316_3400.n1 a_n9316_3400.n0 13.1288
R326 a_n9316_3400.n1 a_n9316_3400.t1 11.5544
C0 IN VBIAS 0.23252f
C1 OUTN OUTP 2.47685f
C2 OUTN VDD 5.99552f
C3 REF VBIAS 2.54517f
C4 OUTP VDD 4.38137f
C5 REF IN 2.51858f
C6 VBIAS VSS 5.26603f
C7 REF VSS 8.38255f
C8 IN VSS 7.34488f
C9 OUTP VSS 3.58841f
C10 OUTN VSS 6.08658f
C11 VDD VSS 0.69728p
C12 a_n9316_3400.n0 VSS 2.68458f
C13 a_n9316_3400.t1 VSS 0.25373f
C14 a_n9316_3400.n1 VSS 2.1951f
C15 a_n9316_3400.t0 VSS 0.94275f
C16 a_n7716_3000.n0 VSS 0.59394f
C17 a_n7716_3000.n1 VSS 3.50711f
C18 a_n7716_3000.t1 VSS 0.60345f
C19 a_n7716_3000.n2 VSS 3.43276f
C20 a_n7716_3000.t0 VSS 1.65741f
C21 a_n9244_3330.t1 VSS 1.28698f
C22 a_n9244_3330.n0 VSS 4.221f
C23 a_n9244_3330.n1 VSS 3.76671f
C24 a_n9244_3330.t0 VSS 1.7604f
C25 a_n1316_n800.t2 VSS 1.07865f
C26 a_n1316_n800.n0 VSS 5.42995f
C27 a_n1316_n800.n1 VSS 1.73632f
C28 a_n1316_n800.t1 VSS 0.97176f
C29 a_n1172_n800.t0 VSS 1.01577f
C30 a_n1172_n800.t3 VSS 1.63038f
C31 a_n1172_n800.n0 VSS 1.42788f
C32 a_n1172_n800.t1 VSS 1.08514f
C33 a_n1172_n800.n1 VSS 0.61622f
C34 a_n1172_n800.t2 VSS 1.09021f
C35 VSS.t3 VSS 0.05979f
C36 VSS.t7 VSS 0.08369f
C37 VSS.t20 VSS 0.10852f
C38 VSS.t18 VSS 0.10851f
C39 VSS.t5 VSS 0.08005f
C40 VSS.t1 VSS 0.09424f
C41 VDD.n0 VSS 0.03661f
C42 VDD.t9 VSS 0.09018f
C43 VDD.t23 VSS 0.0902f
C44 VDD.n1 VSS 0.03119f
C45 VDD.t7 VSS 0.1031f
C46 VDD.t5 VSS 0.10312f
C47 VDD.n2 VSS 0.03085f
C48 VDD.n3 VSS 0.07105f
C49 VDD.t19 VSS 0.03461f
C50 VDD.n4 VSS 0.01969f
C51 VDD.t18 VSS 0.03519f
C52 VDD.n5 VSS 0.04129f
C53 VDD.n6 VSS 0.14041f
C54 VDD.t1 VSS 0.39846f
C55 VDD.n7 VSS 0.08224f
C56 VDD.t3 VSS 0.17052f
C57 VDD.n8 VSS 0.08334f
C58 VDD.t15 VSS 0.03461f
C59 VDD.n9 VSS 0.01969f
C60 VDD.t14 VSS 0.03519f
C61 VDD.n10 VSS 0.04129f
C62 VDD.n11 VSS 0.05186f
C63 VDD.t11 VSS 0.23095f
C64 VDD.n12 VSS 0.07981f
C65 VDD.t21 VSS 0.16625f
C66 VDD.n13 VSS 0.05689f
C67 VDD.t20 VSS 0.8583f
C68 VDD.n14 VSS 0.04069f
C69 VDD.n15 VSS 0.04242f
C70 VDD.n16 VSS 0.0432f
C71 VDD.n17 VSS 0.04242f
C72 VDD.n18 VSS 0.04069f
C73 VDD.n19 VSS 0.04069f
C74 VDD.t0 VSS 1.1444f
C75 VDD.n20 VSS 0.04069f
C76 VDD.n21 VSS 0.04242f
C77 VDD.n22 VSS 3.17315f
C78 VDD.n23 VSS 0.04242f
C79 VDD.n24 VSS 0.04069f
C80 VDD.n25 VSS 1.2697f
C81 VDD.t6 VSS 0.46339f
C82 VDD.t4 VSS 0.76293f
C83 VDD.t8 VSS 0.76293f
C84 VDD.t22 VSS 0.32425f
C85 VDD.n26 VSS 1.1444f
C86 VDD.t17 VSS 1.14648f
C87 VDD.n27 VSS 1.11042f
C88 VDD.n28 VSS 0.04069f
C89 VDD.n29 VSS 0.04242f
C90 VDD.n30 VSS 0.13815f
C91 VDD.n31 VSS 0.0432f
C92 VDD.n32 VSS 0.0432f
C93 VDD.n33 VSS 0.04242f
C94 VDD.n34 VSS 0.04069f
C95 VDD.n35 VSS 1.14857f
C96 VDD.t2 VSS 1.14648f
C97 VDD.n36 VSS 1.1444f
C98 VDD.t13 VSS 1.1444f
C99 VDD.n37 VSS 0.7665f
C100 VDD.t10 VSS 1.14708f
C101 VDD.n38 VSS 1.62279f
C102 VDD.n39 VSS 1.43519f
C103 VDD.n40 VSS 0.04069f
C104 VDD.n41 VSS 0.04242f
C105 VDD.n42 VSS 0.0432f
C106 VDD.n43 VSS 0.0432f
C107 VDD.n44 VSS 0.0432f
C108 VDD.n45 VSS 0.04242f
C109 VDD.n46 VSS 0.03903f
C110 VDD.n47 VSS 1.34429f
C111 VDD.n48 VSS 1.17674f
C112 VDD.n49 VSS 0.03692f
C113 VDD.n50 VSS 0.01726f
C114 OUTN.t0 VSS 0.81259f
C115 OUTN.t2 VSS 0.80731f
C116 OUTN.n0 VSS 0.98926f
C117 OUTN.t1 VSS 0.67809f
C118 OUTN.n1 VSS 1.62371f
C119 OUTN.n2 VSS 0.65932f
C120 OUTN.n3 VSS 2.25549f
C121 OUTN.n4 VSS 1.33555f
C122 OUTP.t0 VSS 0.98352f
C123 OUTP.t2 VSS 0.9771f
C124 OUTP.n0 VSS 1.27452f
C125 OUTP.t1 VSS 0.82675f
C126 OUTP.n1 VSS 2.72454f
C127 VBIAS.n0 VSS 1.00473f
.ends
