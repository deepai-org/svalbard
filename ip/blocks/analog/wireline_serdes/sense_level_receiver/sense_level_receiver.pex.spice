* PEX produced using /foss/tools/sak/sak-pex.sh with m=3 and s=1 (extresist threshold=0 mOhm, minres=1 mOhm, mindelay=0 ps)
* NGSPICE file created from sense_level_receiver_pex.ext - technology: gf180mcuD

.subckt sense_level_receiver_pex IN REF VBIAS VDD VSS OUTP OUTN
X0 a_n7956_3000.t5 a_n9316_3400.t4 VSS.t23 VSS.t22 nfet_03v3 ad=1.56p pd=6.52u as=1.56p ps=6.52u w=6u l=0.28u
X1 a_n1172_n800.t1 VBIAS.t0 VSS.t31 VSS.t30 nfet_03v3 ad=5.28p pd=24.88u as=3.12p ps=12.52u w=12u l=0.28u
X2 OUTP.t0 a_5484_3200.t5 VDD.t15 VDD.t14 pfet_03v3 ad=2.08p pd=8.52u as=2.08p ps=8.52u w=8u l=0.28u
X3 OUTP.t4 a_5484_3200.t2 VSS.t33 VSS.t32 nfet_03v3 ad=2.64p pd=12.88u as=1.56p ps=6.52u w=6u l=0.28u
X4 OUTN.t2 a_n7956_3000.t8 VSS.t1 VSS.t0 nfet_03v3 ad=2.64p pd=12.88u as=1.56p ps=6.52u w=6u l=0.28u
X5 VDD.t3 a_n9316_3400.t7 a_n7956_3000.t1 VDD.t2 pfet_03v3 ad=2.08p pd=8.52u as=2.08p ps=8.52u w=8u l=0.28u
X6 VSS.t25 a_n9244_3330.t2 a_n9316_3400.t0 VSS.t24 nfet_03v3 ad=0.88p pd=4.88u as=0.88p ps=4.88u w=2u l=0.28u
X7 VSS.t9 a_n7956_3000.t12 a_5484_3200.t0 VSS.t8 nfet_03v3 ad=1.76p pd=8.88u as=1.76p ps=8.88u w=4u l=0.28u
X8 VSS.t29 VBIAS.t1 a_n1172_n800.t0 VSS.t28 nfet_03v3 ad=3.12p pd=12.52u as=5.28p ps=24.88u w=12u l=0.28u
X9 VSS.t19 a_n9316_3400.t3 a_n7956_3000.t3 VSS.t18 nfet_03v3 ad=1.56p pd=6.52u as=1.56p ps=6.52u w=6u l=0.28u
X10 a_n7956_3000.t6 a_n9316_3400.t6 VDD.t39 VDD.t38 pfet_03v3 ad=3.52p pd=16.88u as=2.08p ps=8.52u w=8u l=0.28u
X11 VDD.t11 a_n9316_3400.t9 a_n7956_3000.t2 VDD.t10 pfet_03v3 ad=2.08p pd=8.52u as=3.52p ps=16.88u w=8u l=0.28u
X12 OUTN.t4 a_n7956_3000.t10 VSS.t5 VSS.t4 nfet_03v3 ad=1.56p pd=6.52u as=1.56p ps=6.52u w=6u l=0.28u
X13 VSS.t27 a_5484_3200.t3 OUTP.t3 VSS.t26 nfet_03v3 ad=1.56p pd=6.52u as=2.64p ps=12.88u w=6u l=0.28u
X14 VSS.t13 VSS.t10 VSS.t12 VSS.t11 nfet_03v3 ad=3.52p pd=16.88u as=0 ps=0 w=8u l=0.28u
X15 VDD.t23 VDD.t20 VDD.t22 VDD.t21 pfet_03v3 ad=3.52p pd=16.88u as=0 ps=0 w=8u l=0.28u
X16 VSS.t7 a_n7956_3000.t11 OUTN.t5 VSS.t6 nfet_03v3 ad=1.56p pd=6.52u as=2.64p ps=12.88u w=6u l=0.28u
X17 VSS.t17 VSS.t14 VSS.t16 VSS.t15 nfet_03v3 ad=3.52p pd=16.88u as=0 ps=0 w=8u l=0.28u
X18 VDD.t27 VDD.t24 VDD.t26 VDD.t25 pfet_03v3 ad=3.52p pd=16.88u as=0 ps=0 w=8u l=0.28u
X19 VSS.t3 a_n7956_3000.t9 OUTN.t3 VSS.t2 nfet_03v3 ad=1.56p pd=6.52u as=1.56p ps=6.52u w=6u l=0.28u
X20 VDD.t7 a_n7956_3000.t14 OUTN.t1 VDD.t6 pfet_03v3 ad=2.08p pd=8.52u as=2.08p ps=8.52u w=8u l=0.28u
X21 OUTN.t8 a_n7956_3000.t17 VDD.t35 VDD.t34 pfet_03v3 ad=2.08p pd=8.52u as=2.08p ps=8.52u w=8u l=0.28u
X22 a_n1172_n800.t3 IN.t0 a_n1316_n800.t2 VSS.t35 nfet_03v3 ad=3.52p pd=16.88u as=3.52p ps=16.88u w=8u l=0.28u
X23 VDD.t29 a_n1316_n800.t0 a_n1316_n800.t1 VDD.t28 pfet_03v3 ad=3.52p pd=16.88u as=3.52p ps=16.88u w=8u l=0.28u
X24 a_n1172_n800.t2 REF.t0 a_n9244_3330.t1 VSS.t34 nfet_03v3 ad=3.52p pd=16.88u as=3.52p ps=16.88u w=8u l=0.28u
X25 VDD.t41 a_n1316_n800.t3 a_n9244_3330.t0 VDD.t40 pfet_03v3 ad=3.52p pd=16.88u as=3.52p ps=16.88u w=8u l=0.28u
X26 a_n7956_3000.t4 a_n9316_3400.t2 VSS.t21 VSS.t20 nfet_03v3 ad=2.64p pd=12.88u as=1.56p ps=6.52u w=6u l=0.28u
X27 VDD.t17 a_5484_3200.t6 OUTP.t1 VDD.t16 pfet_03v3 ad=2.08p pd=8.52u as=3.52p ps=16.88u w=8u l=0.28u
X28 VDD.t9 a_n9244_3330.t3 a_n9316_3400.t1 VDD.t8 pfet_03v3 ad=1.76p pd=8.88u as=1.76p ps=8.88u w=4u l=0.28u
X29 OUTN.t6 a_n7956_3000.t15 VDD.t31 VDD.t30 pfet_03v3 ad=2.08p pd=8.52u as=2.08p ps=8.52u w=8u l=0.28u
X30 VDD.t37 a_n7956_3000.t18 OUTN.t9 VDD.t36 pfet_03v3 ad=2.08p pd=8.52u as=3.52p ps=16.88u w=8u l=0.28u
X31 VDD.t13 a_n7956_3000.t19 a_5484_3200.t1 VDD.t12 pfet_03v3 ad=3.52p pd=16.88u as=3.52p ps=16.88u w=8u l=0.28u
X32 VDD.t19 a_5484_3200.t4 OUTP.t2 VDD.t18 pfet_03v3 ad=3.52p pd=16.88u as=2.08p ps=8.52u w=8u l=0.28u
X33 OUTN.t0 a_n7956_3000.t13 VDD.t5 VDD.t4 pfet_03v3 ad=3.52p pd=16.88u as=2.08p ps=8.52u w=8u l=0.28u
X34 a_n7956_3000.t0 a_n9316_3400.t8 VDD.t1 VDD.t0 pfet_03v3 ad=2.08p pd=8.52u as=2.08p ps=8.52u w=8u l=0.28u
X35 VDD.t33 a_n7956_3000.t16 OUTN.t7 VDD.t32 pfet_03v3 ad=2.08p pd=8.52u as=2.08p ps=8.52u w=8u l=0.28u
X36 VSS.t37 a_n9316_3400.t5 a_n7956_3000.t7 VSS.t36 nfet_03v3 ad=1.56p pd=6.52u as=2.64p ps=12.88u w=6u l=0.28u
R0 VBIAS.n0 VBIAS.t0 165.774
R1 VBIAS.n0 VBIAS.t1 165.745
R2 VBIAS VBIAS.n0 36.5744
R3 REF REF.t0 162.293
R4 IN IN.t0 160.65
R5 OUTP.n3 OUTP.n1 12.2483
R6 OUTP OUTP.n3 10.2922
R7 OUTP.n2 OUTP.t4 5.80116
R8 OUTP.n2 OUTP.t3 5.61169
R9 OUTP.n1 OUTP.t1 5.59554
R10 OUTP.n1 OUTP.n0 5.46277
R11 OUTP.n3 OUTP.n2 4.77441
R12 OUTP.n0 OUTP.t2 0.228
R13 OUTP.n0 OUTP.t0 0.228
R14 OUTN OUTN.n7 13.0705
R15 OUTN.n7 OUTN.n3 12.5222
R16 OUTN.n5 OUTN.t2 5.80116
R17 OUTN.n1 OUTN.t0 5.73764
R18 OUTN.n3 OUTN.t9 5.73764
R19 OUTN.n6 OUTN.t5 5.70642
R20 OUTN.n5 OUTN.n4 5.33869
R21 OUTN.n1 OUTN.n0 5.32067
R22 OUTN.n3 OUTN.n2 5.32067
R23 OUTN.n7 OUTN.n6 4.5005
R24 OUTN.n4 OUTN.t4 0.2735
R25 OUTN.n4 OUTN.t3 0.2735
R26 OUTN.n0 OUTN.t6 0.228
R27 OUTN.n0 OUTN.t1 0.228
R28 OUTN.n2 OUTN.t8 0.228
R29 OUTN.n2 OUTN.t7 0.228
R30 OUTN.n3 OUTN.n1 0.189974
R31 OUTN.n6 OUTN.n5 0.0952368
R32 VDD.n50 VDD.n49 266.668
R33 VDD.t12 VDD.t36 222.222
R34 VDD.t21 VDD.n47 200
R35 VDD.t28 VDD.n46 200
R36 VDD.n37 VDD.t40 200
R37 VDD.n38 VDD.t25 200
R38 VDD.t4 VDD.n35 200
R39 VDD.n59 VDD.t8 177.779
R40 VDD.n10 VDD.t24 136.986
R41 VDD.n15 VDD.t20 136.986
R42 VDD.t10 VDD.n48 128.889
R43 VDD.n58 VDD.n23 94.5005
R44 VDD.n28 VDD.n23 94.5005
R45 VDD.n51 VDD.n28 94.5005
R46 VDD.n51 VDD.n27 94.5005
R47 VDD.n45 VDD.n27 94.5005
R48 VDD.n45 VDD.n29 94.5005
R49 VDD.n39 VDD.n29 94.5005
R50 VDD.n39 VDD.n33 94.5005
R51 VDD.n34 VDD.n33 94.5005
R52 VDD.n49 VDD.t38 84.4449
R53 VDD.n59 VDD.n58 72.9672
R54 VDD.n50 VDD.t21 66.6672
R55 VDD.n47 VDD.t28 66.6672
R56 VDD.n46 VDD.t40 66.6672
R57 VDD.t25 VDD.n37 66.6672
R58 VDD.n60 VDD.n59 26.4219
R59 VDD.n48 VDD.t8 22.2227
R60 VDD.n38 VDD.t12 22.2227
R61 VDD.n13 VDD.t41 20.2725
R62 VDD.n14 VDD.t29 20.1778
R63 VDD.n9 VDD.t13 18.316
R64 VDD.n22 VDD.t9 18.0802
R65 VDD.n57 VDD.n0 18.0005
R66 VDD.n56 VDD.n55 18.0005
R67 VDD.n54 VDD.n24 18.0005
R68 VDD.n53 VDD.n52 18.0005
R69 VDD.n26 VDD.n25 18.0005
R70 VDD.n44 VDD.n43 18.0005
R71 VDD.n42 VDD.n30 18.0005
R72 VDD.n41 VDD.n40 18.0005
R73 VDD.t0 VDD.t10 17.7783
R74 VDD.t2 VDD.t0 17.7783
R75 VDD.t38 VDD.t2 17.7783
R76 VDD.t36 VDD.t34 17.7783
R77 VDD.t32 VDD.t30 17.7783
R78 VDD.t30 VDD.t6 17.7783
R79 VDD.t6 VDD.t4 17.7783
R80 VDD.t16 VDD.t14 17.7783
R81 VDD.t14 VDD.t18 17.7783
R82 VDD.n8 VDD.n2 14.1183
R83 VDD.n36 VDD.t32 13.3338
R84 VDD.n21 VDD.n20 12.721
R85 VDD.n8 VDD.n7 12.5552
R86 VDD.n11 VDD.t26 10.1192
R87 VDD.n16 VDD.t22 10.1192
R88 VDD.n10 VDD.t27 10.0719
R89 VDD.n15 VDD.t23 10.0719
R90 VDD.n41 VDD.n31 9.42313
R91 VDD.n12 VDD.n11 8.57007
R92 VDD.n17 VDD.n16 8.57007
R93 VDD.n34 VDD.n31 6.96266
R94 VDD.n58 VDD.n57 6.3005
R95 VDD.n48 VDD.n23 6.3005
R96 VDD.n56 VDD.n23 6.3005
R97 VDD.n49 VDD.n28 6.3005
R98 VDD.n28 VDD.n24 6.3005
R99 VDD.n51 VDD.n50 6.3005
R100 VDD.n52 VDD.n51 6.3005
R101 VDD.n47 VDD.n27 6.3005
R102 VDD.n27 VDD.n26 6.3005
R103 VDD.n46 VDD.n45 6.3005
R104 VDD.n45 VDD.n44 6.3005
R105 VDD.n37 VDD.n29 6.3005
R106 VDD.n30 VDD.n29 6.3005
R107 VDD.n39 VDD.n38 6.3005
R108 VDD.n40 VDD.n39 6.3005
R109 VDD.n36 VDD.n33 6.3005
R110 VDD.n33 VDD.n32 6.3005
R111 VDD.n35 VDD.n34 6.3005
R112 VDD.n2 VDD.t19 5.73764
R113 VDD.n5 VDD.n3 5.51014
R114 VDD.n20 VDD.n18 5.51014
R115 VDD.n2 VDD.n1 5.32067
R116 VDD.n5 VDD.n4 5.32067
R117 VDD.n7 VDD.n6 5.32067
R118 VDD.n20 VDD.n19 5.32067
R119 VDD.n61 VDD.n60 5.21103
R120 VDD.t34 VDD.n36 4.44494
R121 VDD.n35 VDD.t16 4.44494
R122 VDD.n14 VDD.n13 2.13208
R123 VDD.n21 VDD.n17 1.94261
R124 VDD.n22 VDD.n21 1.65839
R125 VDD.n12 VDD.n9 1.61103
R126 VDD.n57 VDD.n56 1.3505
R127 VDD.n56 VDD.n24 1.3505
R128 VDD.n52 VDD.n24 1.3505
R129 VDD.n52 VDD.n26 1.3505
R130 VDD.n44 VDD.n26 1.3505
R131 VDD.n44 VDD.n30 1.3505
R132 VDD.n40 VDD.n30 1.3505
R133 VDD.n40 VDD.n32 1.3505
R134 VDD.n11 VDD.n10 1.25267
R135 VDD.n16 VDD.n15 1.25267
R136 VDD.n17 VDD.n14 1.13734
R137 VDD.n13 VDD.n12 0.995237
R138 VDD.n60 VDD.n22 0.687342
R139 VDD.n32 VDD.n31 0.641316
R140 VDD.n55 VDD.n0 0.6005
R141 VDD.n55 VDD.n54 0.6005
R142 VDD.n54 VDD.n53 0.6005
R143 VDD.n53 VDD.n25 0.6005
R144 VDD.n43 VDD.n25 0.6005
R145 VDD.n43 VDD.n42 0.6005
R146 VDD.n42 VDD.n41 0.6005
R147 VDD.n9 VDD.n8 0.592605
R148 VDD.n61 VDD.n0 0.309974
R149 VDD.n1 VDD.t17 0.228
R150 VDD.n1 VDD.t15 0.228
R151 VDD.n3 VDD.t7 0.228
R152 VDD.n3 VDD.t5 0.228
R153 VDD.n4 VDD.t33 0.228
R154 VDD.n4 VDD.t31 0.228
R155 VDD.n6 VDD.t37 0.228
R156 VDD.n6 VDD.t35 0.228
R157 VDD.n19 VDD.t3 0.228
R158 VDD.n19 VDD.t39 0.228
R159 VDD.n18 VDD.t11 0.228
R160 VDD.n18 VDD.t1 0.228
R161 VDD.n7 VDD.n5 0.189974
R162 VDD VDD.n61 0.0205
R163 VSS.n63 VSS.n11 541.668
R164 VSS.t6 VSS.t8 487.5
R165 VSS.n38 VSS.t0 442.361
R166 VSS.t32 VSS.n37 415.279
R167 VSS.n57 VSS.t11 406.25
R168 VSS.n50 VSS.t34 406.25
R169 VSS.n43 VSS.t15 406.25
R170 VSS.n82 VSS.t24 361.111
R171 VSS.n64 VSS.t36 261.807
R172 VSS.t28 VSS.t35 252.779
R173 VSS.n81 VSS.n2 207.639
R174 VSS.t20 VSS.n63 171.529
R175 VSS.n36 VSS.n22 138.25
R176 VSS.n94 VSS.t14 136.776
R177 VSS.n89 VSS.t10 136.776
R178 VSS.n82 VSS.n81 135.417
R179 VSS.t11 VSS.n11 135.417
R180 VSS.n57 VSS.t35 135.417
R181 VSS.t34 VSS.n19 135.417
R182 VSS.n50 VSS.t15 135.417
R183 VSS.n39 VSS.n23 129.5
R184 VSS.n19 VSS.t30 117.362
R185 VSS.n28 VSS.n23 105.001
R186 VSS.n32 VSS.n31 105.001
R187 VSS.n36 VSS.n26 105.001
R188 VSS.n65 VSS.n1 105.001
R189 VSS.n65 VSS.n10 105.001
R190 VSS.n16 VSS.n10 105.001
R191 VSS.n56 VSS.n16 105.001
R192 VSS.n56 VSS.n15 105.001
R193 VSS.n51 VSS.n15 105.001
R194 VSS.n51 VSS.n18 105.001
R195 VSS.n42 VSS.n18 105.001
R196 VSS.n42 VSS.n39 105.001
R197 VSS.n73 VSS.n8 105.001
R198 VSS.n76 VSS.n75 105.001
R199 VSS.n80 VSS.n3 105.001
R200 VSS.n62 VSS.n3 105.001
R201 VSS.n62 VSS.n12 105.001
R202 VSS.n58 VSS.n12 105.001
R203 VSS.n58 VSS.n14 105.001
R204 VSS.n49 VSS.n14 105.001
R205 VSS.n49 VSS.n20 105.001
R206 VSS.n45 VSS.n20 105.001
R207 VSS.n45 VSS.n22 105.001
R208 VSS.n80 VSS.n4 85.7505
R209 VSS.n69 VSS.n1 77.0005
R210 VSS.n64 VSS.t24 45.1394
R211 VSS.t8 VSS.n43 45.1394
R212 VSS.t36 VSS.t22 36.1116
R213 VSS.t22 VSS.t18 36.1116
R214 VSS.t18 VSS.t20 36.1116
R215 VSS.t30 VSS.t28 36.1116
R216 VSS.t2 VSS.t4 36.1116
R217 VSS.t0 VSS.t2 36.1116
R218 VSS.t26 VSS.t32 36.1116
R219 VSS.n44 VSS.t4 27.0838
R220 VSS.n38 VSS.t26 27.0838
R221 VSS.n83 VSS.t25 26.0913
R222 VSS.n83 VSS.n82 25.7462
R223 VSS.n96 VSS.t9 24.8769
R224 VSS.n102 VSS.n101 24.3427
R225 VSS.n100 VSS.n99 18.9098
R226 VSS.n87 VSS.n86 18.744
R227 VSS.n103 VSS.n0 18.3305
R228 VSS.n92 VSS.n91 17.0328
R229 VSS.n93 VSS.t17 11.3897
R230 VSS.n88 VSS.t13 11.3897
R231 VSS.n95 VSS.n94 10.2331
R232 VSS.n90 VSS.n89 10.2331
R233 VSS.n93 VSS.t16 10.2322
R234 VSS.n88 VSS.t12 10.2322
R235 VSS.n44 VSS.t6 9.02828
R236 VSS.n103 VSS.n102 5.70839
R237 VSS.n99 VSS.n97 5.52816
R238 VSS.n86 VSS.n85 5.52816
R239 VSS.n99 VSS.n98 5.33869
R240 VSS.n86 VSS.n84 5.33869
R241 VSS.n39 VSS.n38 5.2005
R242 VSS.n40 VSS.n39 5.2005
R243 VSS.n44 VSS.n42 5.2005
R244 VSS.n42 VSS.n41 5.2005
R245 VSS.n43 VSS.n18 5.2005
R246 VSS.n18 VSS.n17 5.2005
R247 VSS.n51 VSS.n50 5.2005
R248 VSS.n52 VSS.n51 5.2005
R249 VSS.n19 VSS.n15 5.2005
R250 VSS.n53 VSS.n15 5.2005
R251 VSS.n57 VSS.n56 5.2005
R252 VSS.n56 VSS.n55 5.2005
R253 VSS.n16 VSS.n11 5.2005
R254 VSS.n54 VSS.n16 5.2005
R255 VSS.n63 VSS.n10 5.2005
R256 VSS.n10 VSS.n9 5.2005
R257 VSS.n65 VSS.n64 5.2005
R258 VSS.n66 VSS.n65 5.2005
R259 VSS.n81 VSS.n1 5.2005
R260 VSS.n67 VSS.n1 5.2005
R261 VSS.n78 VSS.n4 5.2005
R262 VSS.n77 VSS.n76 5.2005
R263 VSS.n75 VSS.n6 5.2005
R264 VSS.n73 VSS.n72 5.2005
R265 VSS.n71 VSS.n8 5.2005
R266 VSS.n70 VSS.n69 5.2005
R267 VSS.n81 VSS.n80 5.2005
R268 VSS.n80 VSS.n79 5.2005
R269 VSS.n64 VSS.n3 5.2005
R270 VSS.n5 VSS.n3 5.2005
R271 VSS.n63 VSS.n62 5.2005
R272 VSS.n62 VSS.n61 5.2005
R273 VSS.n12 VSS.n11 5.2005
R274 VSS.n60 VSS.n12 5.2005
R275 VSS.n58 VSS.n57 5.2005
R276 VSS.n59 VSS.n58 5.2005
R277 VSS.n19 VSS.n14 5.2005
R278 VSS.n14 VSS.n13 5.2005
R279 VSS.n50 VSS.n49 5.2005
R280 VSS.n49 VSS.n48 5.2005
R281 VSS.n43 VSS.n20 5.2005
R282 VSS.n47 VSS.n20 5.2005
R283 VSS.n45 VSS.n44 5.2005
R284 VSS.n46 VSS.n45 5.2005
R285 VSS.n38 VSS.n22 5.2005
R286 VSS.n22 VSS.n21 5.2005
R287 VSS.n37 VSS.n23 5.2005
R288 VSS.n27 VSS.n23 5.2005
R289 VSS.n29 VSS.n28 5.2005
R290 VSS.n31 VSS.n30 5.2005
R291 VSS.n33 VSS.n32 5.2005
R292 VSS.n34 VSS.n26 5.2005
R293 VSS.n37 VSS.n36 5.2005
R294 VSS.n36 VSS.n35 5.2005
R295 VSS.n7 VSS.n4 4.73237
R296 VSS.n75 VSS.n74 4.73237
R297 VSS.n68 VSS.n8 4.73237
R298 VSS.n28 VSS.n25 4.73237
R299 VSS.n32 VSS.n24 4.73237
R300 VSS.n31 VSS.n25 4.73237
R301 VSS.n26 VSS.n24 4.73237
R302 VSS.n69 VSS.n68 4.73237
R303 VSS.n74 VSS.n73 4.73237
R304 VSS.n76 VSS.n7 4.73237
R305 VSS.n92 VSS.n90 2.55839
R306 VSS.n90 VSS.n87 2.17945
R307 VSS.n35 VSS.n21 1.778
R308 VSS.n95 VSS.n92 1.70576
R309 VSS.n102 VSS.n100 1.42155
R310 VSS.n96 VSS.n95 1.37418
R311 VSS.n67 VSS.n66 1.3505
R312 VSS.n66 VSS.n9 1.3505
R313 VSS.n54 VSS.n9 1.3505
R314 VSS.n55 VSS.n54 1.3505
R315 VSS.n55 VSS.n53 1.3505
R316 VSS.n53 VSS.n52 1.3505
R317 VSS.n52 VSS.n17 1.3505
R318 VSS.n41 VSS.n17 1.3505
R319 VSS.n41 VSS.n40 1.3505
R320 VSS.n71 VSS.n70 1.3505
R321 VSS.n72 VSS.n71 1.3505
R322 VSS.n72 VSS.n6 1.3505
R323 VSS.n77 VSS.n6 1.3505
R324 VSS.n78 VSS.n77 1.3505
R325 VSS.n79 VSS.n5 1.3505
R326 VSS.n61 VSS.n5 1.3505
R327 VSS.n61 VSS.n60 1.3505
R328 VSS.n60 VSS.n59 1.3505
R329 VSS.n59 VSS.n13 1.3505
R330 VSS.n48 VSS.n13 1.3505
R331 VSS.n48 VSS.n47 1.3505
R332 VSS.n47 VSS.n46 1.3505
R333 VSS.n46 VSS.n21 1.3505
R334 VSS.n29 VSS.n27 1.3505
R335 VSS.n30 VSS.n29 1.3505
R336 VSS.n33 VSS.n30 1.3505
R337 VSS.n34 VSS.n33 1.3505
R338 VSS.n35 VSS.n34 1.3505
R339 VSS.n40 VSS.n0 1.193
R340 VSS.n79 VSS.n78 1.103
R341 VSS.n100 VSS.n96 1.06629
R342 VSS.n70 VSS.n67 0.9905
R343 VSS.n87 VSS.n83 0.947868
R344 VSS.n27 VSS.n0 0.473
R345 VSS.n94 VSS.n93 0.293978
R346 VSS.n89 VSS.n88 0.293978
R347 VSS.n101 VSS.t27 0.2735
R348 VSS.n101 VSS.t33 0.2735
R349 VSS.n97 VSS.t3 0.2735
R350 VSS.n97 VSS.t1 0.2735
R351 VSS.n98 VSS.t7 0.2735
R352 VSS.n98 VSS.t5 0.2735
R353 VSS.n84 VSS.t19 0.2735
R354 VSS.n84 VSS.t21 0.2735
R355 VSS.n85 VSS.t37 0.2735
R356 VSS.n85 VSS.t23 0.2735
R357 VSS.n7 VSS.n2 0.235315
R358 VSS.n74 VSS.n2 0.235315
R359 VSS.n68 VSS.n2 0.235315
R360 VSS.n37 VSS.n25 0.235315
R361 VSS.n37 VSS.n24 0.235315
R362 VSS.n91 VSS.t29 0.137
R363 VSS.n91 VSS.t31 0.137
R364 VSS VSS.n103 0.0205
R365 a_n1172_n800.n0 a_n1172_n800.t2 24.5571
R366 a_n1172_n800.n0 a_n1172_n800.t3 12.0158
R367 a_n1172_n800.t1 a_n1172_n800.n1 5.91419
R368 a_n1172_n800.n1 a_n1172_n800.t0 5.72471
R369 a_n1172_n800.n1 a_n1172_n800.n0 5.02155
R370 a_n1316_n800.n0 a_n1316_n800.t3 162.118
R371 a_n1316_n800.n1 a_n1316_n800.t0 136.776
R372 a_n1316_n800.t1 a_n1316_n800.n1 11.6412
R373 a_n1316_n800.n0 a_n1316_n800.t2 10.1375
R374 a_n1316_n800.n1 a_n1316_n800.n0 7.84615
R375 a_n9244_3330.n0 a_n9244_3330.t3 92.4439
R376 a_n9244_3330.n0 a_n9244_3330.t2 58.7421
R377 a_n9244_3330.n1 a_n9244_3330.n0 19.8788
R378 a_n9244_3330.t0 a_n9244_3330.n1 18.2347
R379 a_n9244_3330.n1 a_n9244_3330.t1 11.3897
R380 a_5484_3200.n0 a_5484_3200.t4 113.632
R381 a_5484_3200.n2 a_5484_3200.t6 109.174
R382 a_5484_3200.n1 a_5484_3200.t5 109.174
R383 a_5484_3200.n4 a_5484_3200.t2 87.5599
R384 a_5484_3200.n4 a_5484_3200.t3 87.5312
R385 a_5484_3200.n3 a_5484_3200.n2 18.4942
R386 a_5484_3200.t1 a_5484_3200.n6 18.3129
R387 a_5484_3200.n5 a_5484_3200.n3 17.0794
R388 a_5484_3200.n5 a_5484_3200.n4 16.6044
R389 a_5484_3200.n6 a_5484_3200.n5 13.9505
R390 a_5484_3200.n2 a_5484_3200.n1 11.6805
R391 a_5484_3200.n6 a_5484_3200.t0 10.4377
R392 a_5484_3200.n3 a_5484_3200.n0 7.17687
R393 a_5484_3200.n1 a_5484_3200.n0 4.42851
R394 a_n7956_3000.n17 a_n7956_3000.t19 144.392
R395 a_n7956_3000.n3 a_n7956_3000.t18 113.632
R396 a_n7956_3000.n4 a_n7956_3000.t17 109.174
R397 a_n7956_3000.n5 a_n7956_3000.t16 109.174
R398 a_n7956_3000.n6 a_n7956_3000.t15 109.174
R399 a_n7956_3000.n7 a_n7956_3000.t14 109.174
R400 a_n7956_3000.n8 a_n7956_3000.t13 109.174
R401 a_n7956_3000.n11 a_n7956_3000.t11 87.5599
R402 a_n7956_3000.n17 a_n7956_3000.t12 84.8135
R403 a_n7956_3000.n12 a_n7956_3000.t10 83.1032
R404 a_n7956_3000.n13 a_n7956_3000.t9 83.1032
R405 a_n7956_3000.n14 a_n7956_3000.t8 83.1032
R406 a_n7956_3000.n22 a_n7956_3000.n18 19.3505
R407 a_n7956_3000.n13 a_n7956_3000.n10 18.4942
R408 a_n7956_3000.n15 a_n7956_3000.n14 18.4942
R409 a_n7956_3000.n5 a_n7956_3000.n2 18.4942
R410 a_n7956_3000.n6 a_n7956_3000.n1 18.4942
R411 a_n7956_3000.n7 a_n7956_3000.n0 18.4942
R412 a_n7956_3000.n9 a_n7956_3000.n8 18.4942
R413 a_n7956_3000.n16 a_n7956_3000.n9 16.9189
R414 a_n7956_3000.n23 a_n7956_3000.n22 12.5222
R415 a_n7956_3000.n13 a_n7956_3000.n12 11.6805
R416 a_n7956_3000.n14 a_n7956_3000.n13 11.6805
R417 a_n7956_3000.n5 a_n7956_3000.n4 11.6805
R418 a_n7956_3000.n6 a_n7956_3000.n5 11.6805
R419 a_n7956_3000.n7 a_n7956_3000.n6 11.6805
R420 a_n7956_3000.n8 a_n7956_3000.n7 11.6805
R421 a_n7956_3000.n16 a_n7956_3000.n15 9.4085
R422 a_n7956_3000.n18 a_n7956_3000.n16 7.47441
R423 a_n7956_3000.n11 a_n7956_3000.n10 7.17687
R424 a_n7956_3000.n3 a_n7956_3000.n2 7.17687
R425 a_n7956_3000.n20 a_n7956_3000.t4 5.80116
R426 a_n7956_3000.n24 a_n7956_3000.t6 5.73764
R427 a_n7956_3000.n21 a_n7956_3000.t7 5.70642
R428 a_n7956_3000.n23 a_n7956_3000.t2 5.6429
R429 a_n7956_3000.n20 a_n7956_3000.n19 5.33869
R430 a_n7956_3000.n25 a_n7956_3000.n24 5.32067
R431 a_n7956_3000.n18 a_n7956_3000.n17 4.98963
R432 a_n7956_3000.n22 a_n7956_3000.n21 4.5005
R433 a_n7956_3000.n12 a_n7956_3000.n11 4.42851
R434 a_n7956_3000.n4 a_n7956_3000.n3 4.42851
R435 a_n7956_3000.n19 a_n7956_3000.t5 0.2735
R436 a_n7956_3000.n19 a_n7956_3000.t3 0.2735
R437 a_n7956_3000.t0 a_n7956_3000.n25 0.228
R438 a_n7956_3000.n25 a_n7956_3000.t1 0.228
R439 a_n7956_3000.n15 a_n7956_3000.n10 0.1205
R440 a_n7956_3000.n2 a_n7956_3000.n1 0.1205
R441 a_n7956_3000.n1 a_n7956_3000.n0 0.1205
R442 a_n7956_3000.n9 a_n7956_3000.n0 0.1205
R443 a_n7956_3000.n24 a_n7956_3000.n23 0.0952368
R444 a_n7956_3000.n21 a_n7956_3000.n20 0.0952368
R445 a_n9316_3400.n1 a_n9316_3400.t9 113.632
R446 a_n9316_3400.n2 a_n9316_3400.t8 109.174
R447 a_n9316_3400.n3 a_n9316_3400.t7 109.174
R448 a_n9316_3400.n4 a_n9316_3400.t6 109.174
R449 a_n9316_3400.n7 a_n9316_3400.t5 87.5599
R450 a_n9316_3400.n8 a_n9316_3400.t4 83.1032
R451 a_n9316_3400.n9 a_n9316_3400.t3 83.1032
R452 a_n9316_3400.n10 a_n9316_3400.t2 83.1032
R453 a_n9316_3400.n9 a_n9316_3400.n6 18.4942
R454 a_n9316_3400.n11 a_n9316_3400.n10 18.4942
R455 a_n9316_3400.n3 a_n9316_3400.n0 18.4942
R456 a_n9316_3400.n5 a_n9316_3400.n4 18.4942
R457 a_n9316_3400.t1 a_n9316_3400.n13 18.2696
R458 a_n9316_3400.n12 a_n9316_3400.n5 16.7389
R459 a_n9316_3400.n13 a_n9316_3400.n12 13.1288
R460 a_n9316_3400.n9 a_n9316_3400.n8 11.6805
R461 a_n9316_3400.n10 a_n9316_3400.n9 11.6805
R462 a_n9316_3400.n3 a_n9316_3400.n2 11.6805
R463 a_n9316_3400.n4 a_n9316_3400.n3 11.6805
R464 a_n9316_3400.n13 a_n9316_3400.t0 11.5544
R465 a_n9316_3400.n12 a_n9316_3400.n11 9.1085
R466 a_n9316_3400.n7 a_n9316_3400.n6 7.17687
R467 a_n9316_3400.n1 a_n9316_3400.n0 7.17687
R468 a_n9316_3400.n8 a_n9316_3400.n7 4.42851
R469 a_n9316_3400.n2 a_n9316_3400.n1 4.42851
R470 a_n9316_3400.n11 a_n9316_3400.n6 0.1205
R471 a_n9316_3400.n5 a_n9316_3400.n0 0.1205
C0 REF VBIAS 2.54517f
C1 IN REF 2.51858f
C2 IN VBIAS 0.23252f
C3 OUTN OUTP 0.49323f
C4 OUTN VDD 9.45413f
C5 VDD OUTP 5.23432f
C6 VBIAS VSS 5.26603f
C7 REF VSS 8.38255f
C8 IN VSS 7.34488f
C9 OUTP VSS 4.2677f
C10 OUTN VSS 7.2979f
C11 VDD VSS 0.69683p
C12 a_n9316_3400.n0 VSS 0.17442f
C13 a_n9316_3400.n1 VSS 0.08621f
C14 a_n9316_3400.n2 VSS 0.09241f
C15 a_n9316_3400.n3 VSS 0.09241f
C16 a_n9316_3400.n4 VSS 0.08734f
C17 a_n9316_3400.n5 VSS 0.55788f
C18 a_n9316_3400.n6 VSS 0.17442f
C19 a_n9316_3400.n7 VSS 0.0717f
C20 a_n9316_3400.n8 VSS 0.0782f
C21 a_n9316_3400.n9 VSS 0.0782f
C22 a_n9316_3400.n10 VSS 0.07313f
C23 a_n9316_3400.n11 VSS 0.12964f
C24 a_n9316_3400.n12 VSS 1.92473f
C25 a_n9316_3400.t0 VSS 0.25756f
C26 a_n9316_3400.n13 VSS 2.23743f
C27 a_n9316_3400.t1 VSS 0.95854f
C28 a_n7956_3000.t1 VSS 0.19982f
C29 a_n7956_3000.t6 VSS 0.79221f
C30 a_n7956_3000.t2 VSS 0.79087f
C31 a_n7956_3000.n0 VSS 0.06254f
C32 a_n7956_3000.n1 VSS 0.06254f
C33 a_n7956_3000.n2 VSS 0.18204f
C34 a_n7956_3000.n3 VSS 0.08998f
C35 a_n7956_3000.n4 VSS 0.09645f
C36 a_n7956_3000.n5 VSS 0.09645f
C37 a_n7956_3000.n6 VSS 0.09645f
C38 a_n7956_3000.n7 VSS 0.09645f
C39 a_n7956_3000.n8 VSS 0.09115f
C40 a_n7956_3000.n9 VSS 0.65227f
C41 a_n7956_3000.n10 VSS 0.18204f
C42 a_n7956_3000.n11 VSS 0.07483f
C43 a_n7956_3000.n12 VSS 0.08161f
C44 a_n7956_3000.n13 VSS 0.08161f
C45 a_n7956_3000.n14 VSS 0.07632f
C46 a_n7956_3000.n15 VSS 0.25721f
C47 a_n7956_3000.n16 VSS 1.73372f
C48 a_n7956_3000.n17 VSS 2.45132f
C49 a_n7956_3000.n18 VSS 2.83968f
C50 a_n7956_3000.t4 VSS 0.58524f
C51 a_n7956_3000.t3 VSS 0.15099f
C52 a_n7956_3000.t5 VSS 0.15099f
C53 a_n7956_3000.n19 VSS 0.41955f
C54 a_n7956_3000.n20 VSS 0.2742f
C55 a_n7956_3000.t7 VSS 0.58417f
C56 a_n7956_3000.n21 VSS 0.17996f
C57 a_n7956_3000.n22 VSS 2.91819f
C58 a_n7956_3000.n23 VSS 0.83655f
C59 a_n7956_3000.n24 VSS 0.28114f
C60 a_n7956_3000.n25 VSS 0.57003f
C61 a_n7956_3000.t0 VSS 0.19982f
C62 a_5484_3200.n0 VSS 0.09401f
C63 a_5484_3200.n1 VSS 0.10077f
C64 a_5484_3200.n2 VSS 0.09524f
C65 a_5484_3200.n3 VSS 0.87705f
C66 a_5484_3200.n4 VSS 0.37047f
C67 a_5484_3200.n5 VSS 2.3894f
C68 a_5484_3200.t0 VSS 0.47554f
C69 a_5484_3200.n6 VSS 2.59131f
C70 a_5484_3200.t1 VSS 1.46924f
C71 a_n9244_3330.t1 VSS 1.28832f
C72 a_n9244_3330.n0 VSS 4.22732f
C73 a_n9244_3330.n1 VSS 3.77235f
C74 a_n9244_3330.t0 VSS 1.76252f
C75 a_n1316_n800.t2 VSS 1.07865f
C76 a_n1316_n800.n0 VSS 5.42995f
C77 a_n1316_n800.n1 VSS 1.73632f
C78 a_n1316_n800.t1 VSS 0.97176f
C79 a_n1172_n800.t3 VSS 1.01577f
C80 a_n1172_n800.t2 VSS 1.63038f
C81 a_n1172_n800.n0 VSS 1.42788f
C82 a_n1172_n800.t0 VSS 1.08514f
C83 a_n1172_n800.n1 VSS 0.61622f
C84 a_n1172_n800.t1 VSS 1.09021f
C85 VSS.t25 VSS 0.05988f
C86 VSS.t21 VSS 0.06839f
C87 VSS.t19 VSS 0.06839f
C88 VSS.t23 VSS 0.06839f
C89 VSS.t37 VSS 0.07026f
C90 VSS.t31 VSS 0.10852f
C91 VSS.t29 VSS 0.10851f
C92 VSS.t9 VSS 0.06979f
C93 VSS.t1 VSS 0.07138f
C94 VSS.t3 VSS 0.07138f
C95 VSS.t5 VSS 0.07138f
C96 VSS.t7 VSS 0.07333f
C97 VSS.t33 VSS 0.07662f
C98 VSS.t27 VSS 0.0766f
C99 VDD.n0 VSS 0.05809f
C100 VDD.t19 VSS 0.1443f
C101 VDD.t15 VSS 0.1048f
C102 VDD.t17 VSS 0.1048f
C103 VDD.n1 VSS 0.0362f
C104 VDD.n2 VSS 0.07867f
C105 VDD.t5 VSS 0.10061f
C106 VDD.t7 VSS 0.10061f
C107 VDD.n3 VSS 0.03649f
C108 VDD.t31 VSS 0.10061f
C109 VDD.t33 VSS 0.10061f
C110 VDD.n4 VSS 0.0362f
C111 VDD.n5 VSS 0.01835f
C112 VDD.t35 VSS 0.10061f
C113 VDD.t37 VSS 0.1024f
C114 VDD.n6 VSS 0.0362f
C115 VDD.n7 VSS 0.04369f
C116 VDD.n8 VSS 0.18076f
C117 VDD.t13 VSS 0.2211f
C118 VDD.n9 VSS 0.09217f
C119 VDD.t27 VSS 0.05492f
C120 VDD.n10 VSS 0.03124f
C121 VDD.t26 VSS 0.05584f
C122 VDD.n11 VSS 0.06551f
C123 VDD.n12 VSS 0.07206f
C124 VDD.t41 VSS 0.43279f
C125 VDD.n13 VSS 0.13048f
C126 VDD.t29 VSS 0.20382f
C127 VDD.n14 VSS 0.13223f
C128 VDD.t23 VSS 0.05492f
C129 VDD.n15 VSS 0.03124f
C130 VDD.t22 VSS 0.05584f
C131 VDD.n16 VSS 0.06551f
C132 VDD.n17 VSS 0.08228f
C133 VDD.t1 VSS 0.09669f
C134 VDD.t11 VSS 0.09841f
C135 VDD.n18 VSS 0.03649f
C136 VDD.t39 VSS 0.09669f
C137 VDD.t3 VSS 0.09669f
C138 VDD.n19 VSS 0.0362f
C139 VDD.n20 VSS 0.05827f
C140 VDD.n21 VSS 0.10651f
C141 VDD.t9 VSS 0.18522f
C142 VDD.n22 VSS 0.09027f
C143 VDD.t8 VSS 1.36185f
C144 VDD.n23 VSS 0.06456f
C145 VDD.n24 VSS 0.06731f
C146 VDD.n25 VSS 0.06854f
C147 VDD.n26 VSS 0.06731f
C148 VDD.n27 VSS 0.06456f
C149 VDD.n28 VSS 0.06456f
C150 VDD.t40 VSS 1.8158f
C151 VDD.n29 VSS 0.06456f
C152 VDD.n30 VSS 0.06731f
C153 VDD.n31 VSS 0.09828f
C154 VDD.n32 VSS 0.06731f
C155 VDD.n33 VSS 0.06456f
C156 VDD.t18 VSS 3.21783f
C157 VDD.t14 VSS 0.24211f
C158 VDD.t16 VSS 0.15132f
C159 VDD.n34 VSS 0.10072f
C160 VDD.n35 VSS 1.39211f
C161 VDD.t4 VSS 1.49282f
C162 VDD.t6 VSS 0.24211f
C163 VDD.t30 VSS 0.24211f
C164 VDD.t32 VSS 0.21184f
C165 VDD.n36 VSS 0.12105f
C166 VDD.t34 VSS 0.15132f
C167 VDD.t36 VSS 1.63422f
C168 VDD.t12 VSS 1.66448f
C169 VDD.n37 VSS 1.8158f
C170 VDD.t25 VSS 1.81911f
C171 VDD.n38 VSS 1.51978f
C172 VDD.n39 VSS 0.06456f
C173 VDD.n40 VSS 0.06731f
C174 VDD.n41 VSS 0.2192f
C175 VDD.n42 VSS 0.06854f
C176 VDD.n43 VSS 0.06854f
C177 VDD.n44 VSS 0.06731f
C178 VDD.n45 VSS 0.06456f
C179 VDD.n46 VSS 1.82241f
C180 VDD.t28 VSS 1.81911f
C181 VDD.n47 VSS 1.8158f
C182 VDD.t21 VSS 1.8158f
C183 VDD.n48 VSS 1.03374f
C184 VDD.t10 VSS 1.00382f
C185 VDD.t0 VSS 0.24211f
C186 VDD.t2 VSS 0.24211f
C187 VDD.t38 VSS 0.69606f
C188 VDD.n49 VSS 2.39328f
C189 VDD.n50 VSS 2.27719f
C190 VDD.n51 VSS 0.06456f
C191 VDD.n52 VSS 0.06731f
C192 VDD.n53 VSS 0.06854f
C193 VDD.n54 VSS 0.06854f
C194 VDD.n55 VSS 0.06854f
C195 VDD.n56 VSS 0.06731f
C196 VDD.n57 VSS 0.06193f
C197 VDD.n58 VSS 2.13296f
C198 VDD.n59 VSS 1.86712f
C199 VDD.n60 VSS 0.05858f
C200 VDD.n61 VSS 0.02739f
C201 OUTN.t0 VSS 1.03175f
C202 OUTN.t1 VSS 0.24067f
C203 OUTN.t6 VSS 0.24067f
C204 OUTN.n0 VSS 0.76122f
C205 OUTN.n1 VSS 0.41842f
C206 OUTN.t7 VSS 0.24067f
C207 OUTN.t8 VSS 0.24067f
C208 OUTN.n2 VSS 0.76122f
C209 OUTN.t9 VSS 1.03355f
C210 OUTN.n3 VSS 1.28849f
C211 OUTN.t2 VSS 0.76158f
C212 OUTN.t3 VSS 0.18168f
C213 OUTN.t4 VSS 0.18168f
C214 OUTN.n4 VSS 0.56028f
C215 OUTN.n5 VSS 0.36617f
C216 OUTN.t5 VSS 0.75961f
C217 OUTN.n6 VSS 0.24032f
C218 OUTN.n7 VSS 2.60876f
C219 OUTP.t2 VSS 0.2374f
C220 OUTP.t0 VSS 0.23552f
C221 OUTP.n0 VSS 0.71652f
C222 OUTP.t1 VSS 0.97104f
C223 OUTP.n1 VSS 1.12868f
C224 OUTP.t4 VSS 0.72294f
C225 OUTP.t3 VSS 0.7168f
C226 OUTP.n2 VSS 0.37211f
C227 OUTP.n3 VSS 2.04371f
C228 VBIAS.n0 VSS 1.00473f
.ends
