* SPDX-License-Identifier: Apache-2.0
* Low-input-capacitance single-ended threshold receiver for routed clock/event nodes.
.subckt rlr_inv A Y VDD VSS params: WP=4u WN=2u MP=1 MN=1
XP Y A VDD VDD pfet_03v3 w={WP} l=0.28u m={MP}
XN Y A VSS VSS nfet_03v3 w={WN} l=0.28u m={MN}
.ends rlr_inv

.subckt sense_level_receiver IN REF VBIAS VDD VSS OUTP OUTN
* Small matched input pair: 8x less signal-gate width than clock_level_converter.
XDNL VSS VSS VSS VSS nfet_03v3 w=8u l=0.28u m=1
XIS N1 IN TAIL VSS nfet_03v3 w=8u l=0.28u m=1
XIR N2 REF TAIL VSS nfet_03v3 w=8u l=0.28u m=1
XDNR VSS VSS VSS VSS nfet_03v3 w=8u l=0.28u m=1
XTAIL TAIL VBIAS VSS VSS nfet_03v3 w=12u l=0.28u m=2
XPL N1 N1 VDD VDD pfet_03v3 w=8u l=0.28u m=1
XPR N2 N1 VDD VDD pfet_03v3 w=8u l=0.28u m=1
XDPL VDD VDD VDD VDD pfet_03v3 w=8u l=0.28u m=1
XDPR VDD VDD VDD VDD pfet_03v3 w=8u l=0.28u m=1
* N2 follows IN>REF.  A restoration taper provides both output polarities.
XISO N2 A VDD VSS rlr_inv WP=4u WN=2u MP=1 MN=1
XGAIN A MIDP VDD VSS rlr_inv WP=8u WN=6u MP=4 MN=4
* Generate phase internally, then drive both external loads in parallel.  OUTN
* no longer sits in the control path of OUTP.
XPHASE MIDP MIDN VDD VSS rlr_inv WP=8u WN=4u MP=1 MN=1
XOUTN MIDP OUTN VDD VSS rlr_inv WP=8u WN=6u MP=6 MN=4
XOUTP MIDN OUTP VDD VSS rlr_inv WP=8u WN=6u MP=3 MN=2
.ends sense_level_receiver
