* SPDX-License-Identifier: Apache-2.0
* Typical effective-resistance probe for all eight programmable-load codes.
.include /foss/pdks/gf180mcuD/libs.tech/ngspice/design.ngspice
.lib /foss/pdks/gf180mcuD/libs.tech/ngspice/sm141064.ngspice typical
.lib /foss/pdks/gf180mcuD/libs.tech/ngspice/sm141064.ngspice res_typical
.include /src/programmable_load.spice

VVDD VDD 0 3.3
VOUT OUT 0 2.8
VB0 LOAD_EN0_N 0 3.3
VB1 LOAD_EN1_N 0 3.3
VB2 LOAD_EN2_N 0 3.3
VB3 LOAD_EN3_N 0 3.3
XLOAD OUT LOAD_EN0_N LOAD_EN1_N LOAD_EN2_N LOAD_EN3_N VDD 0 serdes_tx_load

.control
foreach b3 0 3.3
  foreach b2 0 3.3
    foreach b1 0 3.3
      foreach b0 0 3.3
        alter VB0 = $b0
        alter VB1 = $b1
        alter VB2 = $b2
        alter VB3 = $b3
        op
        let reffective = 0.5/i(VOUT)
        echo LOAD_EN_N $b3 $b2 $b1 $b0
        print reffective
      end
    end
  end
end
.endc
.end
