* SPDX-License-Identifier: Apache-2.0
* Full coupled-RC extracted transient verification at 1.25 GBd.
.include /foss/pdks/gf180mcuD/libs.tech/ngspice/design.ngspice
.lib /foss/pdks/gf180mcuD/libs.tech/ngspice/sm141064.ngspice typical
.lib /foss/pdks/gf180mcuD/libs.tech/ngspice/sm141064.ngspice res_typical
.include /work/pex/serdes_tx.pex.spice

VVDD VDD 0 3.3
VBIAS VBIAS 0 1.20
VLOAD0 LOAD_EN0_N 0 0
VLOAD1 LOAD_EN1_N 0 0
VLOAD2 LOAD_EN2_N 0 0
VLOAD3 LOAD_EN3_N 0 0
VINP INP 0 PULSE(0 3.3 100p 20p 20p 380p 800p)
VINN INN 0 PULSE(3.3 0 100p 20p 20p 380p 800p)
CLOAD_P OUTP 0 50f
CLOAD_N OUTN 0 50f
XDUT INP INN OUTP OUTN VBIAS LOAD_EN0_N LOAD_EN1_N LOAD_EN2_N LOAD_EN3_N VDD 0 serdes_tx_pex

.control
tran 2p 8n
let vdiff = v(OUTN)-v(OUTP)
let isupply = -i(VVDD)
meas tran diff_high find vdiff at=2.4n
meas tran diff_low find vdiff at=2.0n
meas tran supply_current_avg avg isupply from=2n to=8n
meas tran output_floor min v(OUTP) from=2n to=8n
meas tran output_floor_n min v(OUTN) from=2n to=8n
meas tran diff_rise trig vdiff val=-0.3 rise=3 targ vdiff val=0.3 rise=3
meas tran diff_fall trig vdiff val=0.3 fall=3 targ vdiff val=-0.3 fall=3
.endc
.end
