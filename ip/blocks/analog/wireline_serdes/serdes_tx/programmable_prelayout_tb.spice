* SPDX-License-Identifier: Apache-2.0
* Nominal 2.5 GT/s proof for the transistor-level programmable-load topology.
.include /foss/pdks/gf180mcuD/libs.tech/ngspice/design.ngspice
.lib /foss/pdks/gf180mcuD/libs.tech/ngspice/sm141064.ngspice typical
.lib /foss/pdks/gf180mcuD/libs.tech/ngspice/sm141064.ngspice res_typical
.include /src/serdes_tx_programmable.spice

VVDD VDD 0 3.3
VBIAS VBIAS 0 1.10
* Typical code: two trim branches enabled low, two disabled high.
VB0 LOAD_EN0_N 0 0
VB1 LOAD_EN1_N 0 0
VB2 LOAD_EN2_N 0 3.3
VB3 LOAD_EN3_N 0 3.3
VINP INP 0 PULSE(0 3.3 100p 20p 20p 180p 400p)
VINN INN 0 PULSE(3.3 0 100p 20p 20p 180p 400p)
CLOAD_P OUTP 0 50f
CLOAD_N OUTN 0 50f
XDUT INP INN OUTP OUTN VBIAS LOAD_EN0_N LOAD_EN1_N LOAD_EN2_N LOAD_EN3_N VDD 0 serdes_tx_programmable

.control
tran 2p 4n
let vdiff = v(OUTN)-v(OUTP)
let isupply = -i(VVDD)
meas tran diff_high find vdiff at=3.2n
meas tran diff_low find vdiff at=3.4n
meas tran supply_current_avg avg isupply from=2n to=4n
meas tran output_floor min v(OUTP) from=2n to=4n
meas tran output_floor_n min v(OUTN) from=2n to=4n
meas tran diff_rise trig vdiff val=-0.3 rise=6 targ vdiff val=0.3 rise=6
meas tran diff_fall trig vdiff val=0.3 fall=6 targ vdiff val=-0.3 fall=6
.endc
.end
