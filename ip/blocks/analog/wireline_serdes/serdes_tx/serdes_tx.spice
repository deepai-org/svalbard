* SPDX-License-Identifier: Apache-2.0
* Experimental GF180 3.3 V CML transmitter output cell.
.subckt serdes_tx INP INN OUTP OUTN VBIAS VDD VSS
XRL_P VDD OUTP VSS ppolyf_s r_width=1u r_length=14.3u
XRL_N VDD OUTN VSS ppolyf_s r_width=1u r_length=14.3u
* Each 200 um effective device is implemented as ten parallel 20 um fingers.
XDIFF_P OUTP INP TAIL VSS nfet_03v3 w=20u l=0.28u m=10
XDIFF_N OUTN INN TAIL VSS nfet_03v3 w=20u l=0.28u m=10
XTAIL TAIL VBIAS VSS VSS nfet_03v3 w=20u l=0.5u m=10
.ends serdes_tx
