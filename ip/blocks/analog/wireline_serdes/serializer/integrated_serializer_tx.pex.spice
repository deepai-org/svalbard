* PEX produced on Thu Aug 20 03:51:22 AM CEST 2026 using /foss/tools/sak/sak-pex.sh with m=3 and s=1 (extresist threshold=0 mOhm, minres=1 mOhm, mindelay=0 ps)
* NGSPICE file created from serializer_tx_pex.ext - technology: gf180mcuD

.subckt serializer_tx_pex EVEN_P EVEN_N ODD_P ODD_N CLK_P CLK_N VBIAS LOAD_EN0_N LOAD_EN1_N
+ LOAD_EN2_N LOAD_EN3_N VDD VSS OUTP OUTN
X0 a_n4756_6400.t3 LOAD_EN2_N.t6 VDD.t7 VDD.t6 pfet_03v3 ad=5.2p pd=20.52u as=5.2p ps=20.52u w=20u l=0.28u
X1 a_n4756_6400.t5 OUTP.t2 VSS.t10 ppolyf_u r_width=1u r_length=0.8u
X2 VDD.t9 LOAD_EN2_N.t5 a_n4756_6400.t4 VDD.t8 pfet_03v3 ad=8.8p pd=40.88u as=5.2p ps=20.52u w=20u l=0.28u
X3 a_n6036_6400.t5 OUTP.t8 VSS.t45 ppolyf_u r_width=1u r_length=0.8u
X4 a_n2292_n6800.t22 CLK_P.t4 a_n3292_n2000.t10 VSS.t63 nfet_03v3 ad=5.2p pd=20.52u as=8.8p ps=40.88u w=20u l=0.28u
X5 a_n2196_6400.t5 OUTP.t9 VSS.t47 ppolyf_u r_width=1u r_length=0.8u
X6 a_n3292_n2000.t13 CLK_P.t1 a_n2292_n6800.t21 VSS.t66 nfet_03v3 ad=5.2p pd=20.52u as=5.2p ps=20.52u w=20u l=0.28u
X7 VDD.t69 LOAD_EN0_N.t5 a_n2196_6400.t4 VDD.t68 pfet_03v3 ad=8.8p pd=40.88u as=5.2p ps=20.52u w=20u l=0.28u
X8 a_n2292_n6800.t17 CLK_N.t2 a_n1292_n2000.t12 VSS.t60 nfet_03v3 ad=5.2p pd=20.52u as=5.2p ps=20.52u w=20u l=0.28u
X9 VSS.t17 VBIAS.t11 a_n2292_n6800.t2 VSS.t16 nfet_03v3 ad=5.2p pd=20.52u as=5.2p ps=20.52u w=20u l=0.5u
X10 a_n2292_n6800.t3 VBIAS.t10 VSS.t21 VSS.t20 nfet_03v3 ad=5.2p pd=20.52u as=5.2p ps=20.52u w=20u l=0.5u
X11 VDD.t21 LOAD_EN3_N.t9 a_n6036_6400.t0 VDD.t20 pfet_03v3 ad=5.2p pd=20.52u as=8.8p ps=40.88u w=20u l=0.28u
X12 VDD.t19 LOAD_EN2_N.t0 a_3884_6400.t4 VDD.t18 pfet_03v3 ad=8.8p pd=40.88u as=5.2p ps=20.52u w=20u l=0.28u
X13 a_n1292_n2000.t9 ODD_P.t0 OUTP.t4 VSS.t15 nfet_03v3 ad=8.8p pd=40.88u as=5.2p ps=20.52u w=20u l=0.28u
X14 VDD.t39 LOAD_EN3_N.t0 a_5164_6400.t5 VDD.t38 pfet_03v3 ad=8.8p pd=40.88u as=5.2p ps=20.52u w=20u l=0.28u
X15 a_n3292_n2000.t4 EVEN_P.t0 OUTP.t11 VSS.t52 nfet_03v3 ad=8.8p pd=40.88u as=5.2p ps=20.52u w=20u l=0.28u
X16 OUTN.t10 EVEN_N.t3 a_n3292_n2000.t6 VSS.t54 nfet_03v3 ad=5.2p pd=20.52u as=5.2p ps=20.52u w=20u l=0.28u
X17 a_5164_6400.t4 LOAD_EN3_N.t1 VDD.t35 VDD.t34 pfet_03v3 ad=5.2p pd=20.52u as=5.2p ps=20.52u w=20u l=0.28u
X18 a_n3476_6400.t0 OUTP.t0 VSS.t6 ppolyf_u r_width=1u r_length=0.8u
X19 a_n3292_n2000.t11 CLK_P.t3 a_n2292_n6800.t23 VSS.t64 nfet_03v3 ad=5.2p pd=20.52u as=5.2p ps=20.52u w=20u l=0.28u
X20 a_n2292_n6800.t14 CLK_N.t0 a_n1292_n2000.t14 VSS.t62 nfet_03v3 ad=8.8p pd=40.88u as=5.2p ps=20.52u w=20u l=0.28u
X21 VSS.t41 VBIAS.t1 a_n2292_n6800.t12 VSS.t40 nfet_03v3 ad=5.2p pd=20.52u as=5.2p ps=20.52u w=20u l=0.5u
X22 a_n2292_n6800.t13 VBIAS.t0 VSS.t43 VSS.t42 nfet_03v3 ad=8.8p pd=40.88u as=5.2p ps=20.52u w=20u l=0.5u
X23 a_5164_6400.t0 OUTN.t0 VSS.t0 ppolyf_u r_width=1u r_length=0.8u
X24 VDD.t61 OUTN.t9 VSS.t46 ppolyf_u r_width=1u r_length=0.8u
X25 a_n3292_n2000.t2 EVEN_P.t2 OUTP.t12 VSS.t50 nfet_03v3 ad=5.2p pd=20.52u as=5.2p ps=20.52u w=20u l=0.28u
X26 OUTN.t1 ODD_N.t3 a_n1292_n2000.t1 VSS.t2 nfet_03v3 ad=5.2p pd=20.52u as=5.2p ps=20.52u w=20u l=0.28u
X27 OUTN.t13 EVEN_N.t1 a_n3292_n2000.t8 VSS.t56 nfet_03v3 ad=5.2p pd=20.52u as=5.2p ps=20.52u w=20u l=0.28u
X28 VDD.t1 LOAD_EN2_N.t9 a_n4756_6400.t0 VDD.t0 pfet_03v3 ad=5.2p pd=20.52u as=8.8p ps=40.88u w=20u l=0.28u
X29 VDD.t60 LOAD_EN1_N.t0 a_2604_6400.t4 VDD.t59 pfet_03v3 ad=8.8p pd=40.88u as=5.2p ps=20.52u w=20u l=0.28u
X30 a_2604_6400.t5 OUTN.t8 VSS.t44 ppolyf_u r_width=1u r_length=0.8u
X31 a_n1292_n2000.t7 ODD_P.t2 OUTP.t6 VSS.t13 nfet_03v3 ad=5.2p pd=20.52u as=5.2p ps=20.52u w=20u l=0.28u
X32 OUTN.t3 ODD_N.t1 a_n1292_n2000.t3 VSS.t4 nfet_03v3 ad=5.2p pd=20.52u as=5.2p ps=20.52u w=20u l=0.28u
X33 a_n4756_6400.t1 LOAD_EN2_N.t8 VDD.t3 VDD.t2 pfet_03v3 ad=5.2p pd=20.52u as=5.2p ps=20.52u w=20u l=0.28u
X34 a_n3292_n2000.t5 EVEN_N.t4 OUTN.t12 VSS.t53 nfet_03v3 ad=5.2p pd=20.52u as=8.8p ps=40.88u w=20u l=0.28u
X35 a_n6036_6400.t1 LOAD_EN3_N.t8 VDD.t23 VDD.t22 pfet_03v3 ad=5.2p pd=20.52u as=5.2p ps=20.52u w=20u l=0.28u
X36 a_3884_6400.t3 LOAD_EN2_N.t1 VDD.t17 VDD.t16 pfet_03v3 ad=5.2p pd=20.52u as=5.2p ps=20.52u w=20u l=0.28u
X37 VSS.t33 VBIAS.t5 a_n2292_n6800.t8 VSS.t32 nfet_03v3 ad=5.2p pd=20.52u as=5.2p ps=20.52u w=20u l=0.5u
X38 VDD.t25 LOAD_EN3_N.t7 a_n6036_6400.t2 VDD.t24 pfet_03v3 ad=5.2p pd=20.52u as=5.2p ps=20.52u w=20u l=0.28u
X39 a_n2196_6400.t1 LOAD_EN0_N.t8 VDD.t65 VDD.t64 pfet_03v3 ad=5.2p pd=20.52u as=5.2p ps=20.52u w=20u l=0.28u
X40 VDD.t37 LOAD_EN3_N.t2 a_5164_6400.t3 VDD.t36 pfet_03v3 ad=5.2p pd=20.52u as=5.2p ps=20.52u w=20u l=0.28u
X41 a_3884_6400.t5 OUTN.t6 VSS.t8 ppolyf_u r_width=1u r_length=0.8u
X42 a_n1292_n2000.t0 ODD_N.t4 OUTN.t4 VSS.t1 nfet_03v3 ad=5.2p pd=20.52u as=8.8p ps=40.88u w=20u l=0.28u
X43 a_n2292_n6800.t7 VBIAS.t6 VSS.t31 VSS.t30 nfet_03v3 ad=5.2p pd=20.52u as=5.2p ps=20.52u w=20u l=0.5u
X44 VDD.t63 LOAD_EN0_N.t9 a_n2196_6400.t0 VDD.t62 pfet_03v3 ad=5.2p pd=20.52u as=8.8p ps=40.88u w=20u l=0.28u
X45 a_1324_6400.t4 LOAD_EN0_N.t1 VDD.t79 VDD.t78 pfet_03v3 ad=5.2p pd=20.52u as=5.2p ps=20.52u w=20u l=0.28u
X46 a_5164_6400.t2 LOAD_EN3_N.t3 VDD.t33 VDD.t32 pfet_03v3 ad=5.2p pd=20.52u as=5.2p ps=20.52u w=20u l=0.28u
X47 a_n3292_n2000.t0 EVEN_P.t4 OUTP.t14 VSS.t48 nfet_03v3 ad=5.2p pd=20.52u as=8.8p ps=40.88u w=20u l=0.28u
X48 VDD.t46 LOAD_EN1_N.t9 a_n3476_6400.t1 VDD.t45 pfet_03v3 ad=5.2p pd=20.52u as=8.8p ps=40.88u w=20u l=0.28u
X49 VDD.t77 LOAD_EN0_N.t2 a_1324_6400.t3 VDD.t76 pfet_03v3 ad=5.2p pd=20.52u as=5.2p ps=20.52u w=20u l=0.28u
X50 VDD.t81 LOAD_EN0_N.t0 a_1324_6400.t5 VDD.t80 pfet_03v3 ad=8.8p pd=40.88u as=5.2p ps=20.52u w=20u l=0.28u
X51 a_1324_6400.t0 OUTN.t7 VSS.t9 ppolyf_u r_width=1u r_length=0.8u
X52 OUTP.t3 ODD_P.t1 a_n1292_n2000.t8 VSS.t14 nfet_03v3 ad=5.2p pd=20.52u as=5.2p ps=20.52u w=20u l=0.28u
X53 a_n3476_6400.t2 LOAD_EN1_N.t8 VDD.t42 VDD.t41 pfet_03v3 ad=5.2p pd=20.52u as=5.2p ps=20.52u w=20u l=0.28u
X54 a_n3476_6400.t4 LOAD_EN1_N.t6 VDD.t50 VDD.t49 pfet_03v3 ad=5.2p pd=20.52u as=5.2p ps=20.52u w=20u l=0.28u
X55 a_n1292_n2000.t5 ODD_P.t4 OUTP.t7 VSS.t11 nfet_03v3 ad=5.2p pd=20.52u as=8.8p ps=40.88u w=20u l=0.28u
X56 a_2604_6400.t1 LOAD_EN1_N.t3 VDD.t56 VDD.t55 pfet_03v3 ad=5.2p pd=20.52u as=5.2p ps=20.52u w=20u l=0.28u
X57 a_2604_6400.t3 LOAD_EN1_N.t1 VDD.t54 VDD.t53 pfet_03v3 ad=5.2p pd=20.52u as=5.2p ps=20.52u w=20u l=0.28u
X58 OUTP.t10 EVEN_P.t1 a_n3292_n2000.t3 VSS.t51 nfet_03v3 ad=5.2p pd=20.52u as=5.2p ps=20.52u w=20u l=0.28u
X59 a_n3292_n2000.t7 EVEN_N.t2 OUTN.t11 VSS.t55 nfet_03v3 ad=5.2p pd=20.52u as=5.2p ps=20.52u w=20u l=0.28u
X60 a_n2292_n6800.t19 CLK_P.t0 a_n3292_n2000.t14 VSS.t67 nfet_03v3 ad=8.8p pd=40.88u as=5.2p ps=20.52u w=20u l=0.28u
X61 a_n1292_n2000.t11 CLK_N.t3 a_n2292_n6800.t16 VSS.t59 nfet_03v3 ad=5.2p pd=20.52u as=5.2p ps=20.52u w=20u l=0.28u
X62 VDD.t5 LOAD_EN2_N.t7 a_n4756_6400.t2 VDD.t4 pfet_03v3 ad=5.2p pd=20.52u as=5.2p ps=20.52u w=20u l=0.28u
X63 VDD.t58 LOAD_EN1_N.t2 a_2604_6400.t2 VDD.t57 pfet_03v3 ad=5.2p pd=20.52u as=5.2p ps=20.52u w=20u l=0.28u
X64 VDD.t11 LOAD_EN2_N.t4 a_3884_6400.t0 VDD.t10 pfet_03v3 ad=5.2p pd=20.52u as=8.8p ps=40.88u w=20u l=0.28u
X65 VDD.t15 LOAD_EN2_N.t2 a_3884_6400.t2 VDD.t14 pfet_03v3 ad=5.2p pd=20.52u as=5.2p ps=20.52u w=20u l=0.28u
X66 VSS.t37 VBIAS.t3 a_n2292_n6800.t10 VSS.t36 nfet_03v3 ad=5.2p pd=20.52u as=5.2p ps=20.52u w=20u l=0.5u
X67 a_n2292_n6800.t11 VBIAS.t2 VSS.t39 VSS.t38 nfet_03v3 ad=5.2p pd=20.52u as=5.2p ps=20.52u w=20u l=0.5u
X68 a_n6036_6400.t3 LOAD_EN3_N.t6 VDD.t27 VDD.t26 pfet_03v3 ad=5.2p pd=20.52u as=5.2p ps=20.52u w=20u l=0.28u
X69 a_3884_6400.t1 LOAD_EN2_N.t3 VDD.t13 VDD.t12 pfet_03v3 ad=5.2p pd=20.52u as=5.2p ps=20.52u w=20u l=0.28u
X70 OUTP.t13 EVEN_P.t3 a_n3292_n2000.t1 VSS.t49 nfet_03v3 ad=5.2p pd=20.52u as=5.2p ps=20.52u w=20u l=0.28u
X71 a_n1292_n2000.t2 ODD_N.t2 OUTN.t2 VSS.t3 nfet_03v3 ad=5.2p pd=20.52u as=5.2p ps=20.52u w=20u l=0.28u
X72 a_n3292_n2000.t9 EVEN_N.t0 OUTN.t14 VSS.t57 nfet_03v3 ad=8.8p pd=40.88u as=5.2p ps=20.52u w=20u l=0.28u
X73 a_n2292_n6800.t20 CLK_P.t2 a_n3292_n2000.t12 VSS.t65 nfet_03v3 ad=5.2p pd=20.52u as=5.2p ps=20.52u w=20u l=0.28u
X74 a_n1292_n2000.t13 CLK_N.t1 a_n2292_n6800.t18 VSS.t61 nfet_03v3 ad=5.2p pd=20.52u as=5.2p ps=20.52u w=20u l=0.28u
X75 a_n2292_n6800.t9 VBIAS.t4 VSS.t35 VSS.t34 nfet_03v3 ad=5.2p pd=20.52u as=5.2p ps=20.52u w=20u l=0.5u
X76 VDD.t29 LOAD_EN3_N.t5 a_n6036_6400.t4 VDD.t28 pfet_03v3 ad=8.8p pd=40.88u as=5.2p ps=20.52u w=20u l=0.28u
X77 VDD.t67 LOAD_EN0_N.t7 a_n2196_6400.t2 VDD.t66 pfet_03v3 ad=5.2p pd=20.52u as=5.2p ps=20.52u w=20u l=0.28u
X78 VDD.t40 OUTP.t1 VSS.t7 ppolyf_u r_width=1u r_length=0.8u
X79 OUTP.t5 ODD_P.t3 a_n1292_n2000.t6 VSS.t12 nfet_03v3 ad=5.2p pd=20.52u as=5.2p ps=20.52u w=20u l=0.28u
X80 a_n1292_n2000.t4 ODD_N.t0 OUTN.t5 VSS.t5 nfet_03v3 ad=8.8p pd=40.88u as=5.2p ps=20.52u w=20u l=0.28u
X81 VSS.t25 VBIAS.t9 a_n2292_n6800.t4 VSS.t24 nfet_03v3 ad=5.2p pd=20.52u as=5.2p ps=20.52u w=20u l=0.5u
X82 a_n2196_6400.t3 LOAD_EN0_N.t6 VDD.t71 VDD.t70 pfet_03v3 ad=5.2p pd=20.52u as=5.2p ps=20.52u w=20u l=0.28u
X83 VDD.t31 LOAD_EN3_N.t4 a_5164_6400.t1 VDD.t30 pfet_03v3 ad=5.2p pd=20.52u as=8.8p ps=40.88u w=20u l=0.28u
X84 VSS.t19 VBIAS.t13 a_n2292_n6800.t0 VSS.t18 nfet_03v3 ad=5.2p pd=20.52u as=8.8p ps=40.88u w=20u l=0.5u
X85 a_n2292_n6800.t1 VBIAS.t12 VSS.t23 VSS.t22 nfet_03v3 ad=5.2p pd=20.52u as=5.2p ps=20.52u w=20u l=0.5u
X86 a_n2292_n6800.t5 VBIAS.t8 VSS.t27 VSS.t26 nfet_03v3 ad=5.2p pd=20.52u as=5.2p ps=20.52u w=20u l=0.5u
X87 VSS.t29 VBIAS.t7 a_n2292_n6800.t6 VSS.t28 nfet_03v3 ad=5.2p pd=20.52u as=5.2p ps=20.52u w=20u l=0.5u
X88 a_1324_6400.t2 LOAD_EN0_N.t3 VDD.t75 VDD.t74 pfet_03v3 ad=5.2p pd=20.52u as=5.2p ps=20.52u w=20u l=0.28u
X89 a_n2292_n6800.t15 CLK_N.t4 a_n1292_n2000.t10 VSS.t58 nfet_03v3 ad=5.2p pd=20.52u as=8.8p ps=40.88u w=20u l=0.28u
X90 VDD.t48 LOAD_EN1_N.t7 a_n3476_6400.t3 VDD.t47 pfet_03v3 ad=5.2p pd=20.52u as=5.2p ps=20.52u w=20u l=0.28u
X91 VDD.t52 LOAD_EN1_N.t5 a_n3476_6400.t5 VDD.t51 pfet_03v3 ad=8.8p pd=40.88u as=5.2p ps=20.52u w=20u l=0.28u
X92 VDD.t73 LOAD_EN0_N.t4 a_1324_6400.t1 VDD.t72 pfet_03v3 ad=5.2p pd=20.52u as=8.8p ps=40.88u w=20u l=0.28u
X93 VDD.t44 LOAD_EN1_N.t4 a_2604_6400.t0 VDD.t43 pfet_03v3 ad=5.2p pd=20.52u as=8.8p ps=40.88u w=20u l=0.28u
R0 VBIAS.n15 VBIAS.t0 157.083
R1 VBIAS.n3 VBIAS.t13 157.083
R2 VBIAS.n16 VBIAS.t1 148.555
R3 VBIAS.n17 VBIAS.t2 148.555
R4 VBIAS.n18 VBIAS.t3 148.555
R5 VBIAS.n19 VBIAS.t4 148.555
R6 VBIAS.n20 VBIAS.t5 148.555
R7 VBIAS.n21 VBIAS.t6 148.555
R8 VBIAS.n22 VBIAS.t7 148.555
R9 VBIAS.n10 VBIAS.t8 148.555
R10 VBIAS.n9 VBIAS.t9 148.555
R11 VBIAS.n2 VBIAS.t10 148.555
R12 VBIAS.n5 VBIAS.t11 148.555
R13 VBIAS.n4 VBIAS.t12 148.555
R14 VBIAS.n17 VBIAS.n16 29.7845
R15 VBIAS.n18 VBIAS.n17 29.7845
R16 VBIAS.n19 VBIAS.n18 29.7845
R17 VBIAS.n20 VBIAS.n19 29.7845
R18 VBIAS.n21 VBIAS.n20 29.7845
R19 VBIAS.n22 VBIAS.n21 29.7845
R20 VBIAS.n22 VBIAS.n10 29.7845
R21 VBIAS.n10 VBIAS.n9 29.7845
R22 VBIAS.n9 VBIAS.n2 29.7845
R23 VBIAS.n5 VBIAS.n2 29.7845
R24 VBIAS.n5 VBIAS.n4 29.7845
R25 VBIAS.n17 VBIAS.n14 19.4067
R26 VBIAS.n18 VBIAS.n13 19.4067
R27 VBIAS.n19 VBIAS.n12 19.4067
R28 VBIAS.n20 VBIAS.n11 19.4067
R29 VBIAS.n21 VBIAS.n0 19.4067
R30 VBIAS.n23 VBIAS.n22 19.4067
R31 VBIAS.n10 VBIAS.n1 19.4067
R32 VBIAS.n9 VBIAS.n8 19.4067
R33 VBIAS.n7 VBIAS.n2 19.4067
R34 VBIAS.n6 VBIAS.n5 19.4067
R35 VBIAS.n16 VBIAS.n15 8.40827
R36 VBIAS.n4 VBIAS.n3 8.40827
R37 VBIAS.n6 VBIAS.n3 5.67508
R38 VBIAS.n15 VBIAS.n14 5.67508
R39 VBIAS.n7 VBIAS.n6 0.1535
R40 VBIAS.n8 VBIAS.n7 0.1535
R41 VBIAS.n8 VBIAS.n1 0.1535
R42 VBIAS.n23 VBIAS.n1 0.1535
R43 VBIAS.n11 VBIAS.n0 0.1535
R44 VBIAS.n12 VBIAS.n11 0.1535
R45 VBIAS.n13 VBIAS.n12 0.1535
R46 VBIAS.n14 VBIAS.n13 0.1535
R47 VBIAS VBIAS.n0 0.137
R48 VBIAS VBIAS.n23 0.017
R49 CLK_N.n2 CLK_N.t0 270.06
R50 CLK_N.n3 CLK_N.t1 265.603
R51 CLK_N.n4 CLK_N.t2 265.603
R52 CLK_N.n5 CLK_N.t3 265.603
R53 CLK_N.n6 CLK_N.t4 265.603
R54 CLK_N.n4 CLK_N.n1 18.4942
R55 CLK_N.n5 CLK_N.n0 18.4942
R56 CLK_N.n7 CLK_N.n6 18.4942
R57 CLK_N.n4 CLK_N.n3 11.6805
R58 CLK_N.n5 CLK_N.n4 11.6805
R59 CLK_N.n6 CLK_N.n5 11.6805
R60 CLK_N.n2 CLK_N.n1 7.17687
R61 CLK_N.n3 CLK_N.n2 4.42851
R62 CLK_N.n7 CLK_N.n0 0.1205
R63 CLK_N.n1 CLK_N.n0 0.1205
R64 CLK_N CLK_N.n7 0.053
R65 CLK_P.n2 CLK_P.t0 270.06
R66 CLK_P.n3 CLK_P.t1 265.603
R67 CLK_P.n4 CLK_P.t2 265.603
R68 CLK_P.n5 CLK_P.t3 265.603
R69 CLK_P.n6 CLK_P.t4 265.603
R70 CLK_P.n4 CLK_P.n1 18.4942
R71 CLK_P.n5 CLK_P.n0 18.4942
R72 CLK_P.n7 CLK_P.n6 18.4942
R73 CLK_P.n4 CLK_P.n3 11.6805
R74 CLK_P.n5 CLK_P.n4 11.6805
R75 CLK_P.n6 CLK_P.n5 11.6805
R76 CLK_P.n2 CLK_P.n1 7.17687
R77 CLK_P.n3 CLK_P.n2 4.42851
R78 CLK_P.n7 CLK_P.n0 0.1205
R79 CLK_P.n1 CLK_P.n0 0.1205
R80 CLK_P CLK_P.n7 0.053
R81 EVEN_N.n2 EVEN_N.t0 270.06
R82 EVEN_N.n3 EVEN_N.t1 265.603
R83 EVEN_N.n4 EVEN_N.t2 265.603
R84 EVEN_N.n5 EVEN_N.t3 265.603
R85 EVEN_N.n6 EVEN_N.t4 265.603
R86 EVEN_N.n4 EVEN_N.n1 18.4942
R87 EVEN_N.n5 EVEN_N.n0 18.4942
R88 EVEN_N.n7 EVEN_N.n6 18.4942
R89 EVEN_N.n4 EVEN_N.n3 11.6805
R90 EVEN_N.n5 EVEN_N.n4 11.6805
R91 EVEN_N.n6 EVEN_N.n5 11.6805
R92 EVEN_N.n2 EVEN_N.n1 7.17687
R93 EVEN_N.n3 EVEN_N.n2 4.42851
R94 EVEN_N.n7 EVEN_N.n0 0.1205
R95 EVEN_N.n1 EVEN_N.n0 0.1205
R96 EVEN_N EVEN_N.n7 0.053
R97 ODD_N.n2 ODD_N.t0 270.06
R98 ODD_N.n3 ODD_N.t1 265.603
R99 ODD_N.n4 ODD_N.t2 265.603
R100 ODD_N.n5 ODD_N.t3 265.603
R101 ODD_N.n6 ODD_N.t4 265.603
R102 ODD_N.n4 ODD_N.n1 18.4942
R103 ODD_N.n5 ODD_N.n0 18.4942
R104 ODD_N.n7 ODD_N.n6 18.4942
R105 ODD_N.n4 ODD_N.n3 11.6805
R106 ODD_N.n5 ODD_N.n4 11.6805
R107 ODD_N.n6 ODD_N.n5 11.6805
R108 ODD_N.n2 ODD_N.n1 7.17687
R109 ODD_N.n3 ODD_N.n2 4.42851
R110 ODD_N.n7 ODD_N.n0 0.1205
R111 ODD_N.n1 ODD_N.n0 0.1205
R112 ODD_N ODD_N.n7 0.053
R113 ODD_P.n2 ODD_P.t0 270.06
R114 ODD_P.n3 ODD_P.t1 265.603
R115 ODD_P.n4 ODD_P.t2 265.603
R116 ODD_P.n5 ODD_P.t3 265.603
R117 ODD_P.n6 ODD_P.t4 265.603
R118 ODD_P.n4 ODD_P.n1 18.4942
R119 ODD_P.n5 ODD_P.n0 18.4942
R120 ODD_P.n7 ODD_P.n6 18.4942
R121 ODD_P.n4 ODD_P.n3 11.6805
R122 ODD_P.n5 ODD_P.n4 11.6805
R123 ODD_P.n6 ODD_P.n5 11.6805
R124 ODD_P.n2 ODD_P.n1 7.17687
R125 ODD_P.n3 ODD_P.n2 4.42851
R126 ODD_P.n7 ODD_P.n0 0.1205
R127 ODD_P.n1 ODD_P.n0 0.1205
R128 ODD_P ODD_P.n7 0.053
R129 EVEN_P.n2 EVEN_P.t0 270.06
R130 EVEN_P.n3 EVEN_P.t1 265.603
R131 EVEN_P.n4 EVEN_P.t2 265.603
R132 EVEN_P.n5 EVEN_P.t3 265.603
R133 EVEN_P.n6 EVEN_P.t4 265.603
R134 EVEN_P.n4 EVEN_P.n1 18.4942
R135 EVEN_P.n5 EVEN_P.n0 18.4942
R136 EVEN_P.n7 EVEN_P.n6 18.4942
R137 EVEN_P.n4 EVEN_P.n3 11.6805
R138 EVEN_P.n5 EVEN_P.n4 11.6805
R139 EVEN_P.n6 EVEN_P.n5 11.6805
R140 EVEN_P.n2 EVEN_P.n1 7.17687
R141 EVEN_P.n3 EVEN_P.n2 4.42851
R142 EVEN_P.n7 EVEN_P.n0 0.1205
R143 EVEN_P.n1 EVEN_P.n0 0.1205
R144 EVEN_P EVEN_P.n7 0.053
R145 OUTN.n0 OUTN.t9 15.8895
R146 OUTN.n0 OUTN.t0 15.4095
R147 OUTN.n1 OUTN.t6 15.4095
R148 OUTN.n2 OUTN.t8 15.4095
R149 OUTN.n3 OUTN.t7 15.4095
R150 OUTN.n4 OUTN.t4 7.86957
R151 OUTN.n11 OUTN.n10 7.78767
R152 OUTN.n14 OUTN.t12 7.77479
R153 OUTN.n8 OUTN.n5 7.69289
R154 OUTN.n7 OUTN.n6 7.69289
R155 OUTN.n13 OUTN.n12 7.69289
R156 OUTN.n15 OUTN.n14 4.5005
R157 OUTN.n9 OUTN.n8 4.5005
R158 OUTN.n15 OUTN.n11 2.38404
R159 OUTN.n9 OUTN.n4 2.38404
R160 OUTN.n2 OUTN.n1 0.4805
R161 OUTN.n1 OUTN.n0 0.4805
R162 OUTN.n3 OUTN.n2 0.413
R163 OUTN OUTN.n3 0.386214
R164 OUTN.n16 OUTN.n15 0.2975
R165 OUTN.n8 OUTN.n7 0.189974
R166 OUTN.n14 OUTN.n13 0.189974
R167 OUTN.n16 OUTN.n9 0.1895
R168 OUTN.n13 OUTN.n11 0.092352
R169 OUTN.n7 OUTN.n4 0.092352
R170 OUTN.n5 OUTN.t3 0.0824
R171 OUTN.n5 OUTN.t5 0.0824
R172 OUTN.n6 OUTN.t1 0.0824
R173 OUTN.n6 OUTN.t2 0.0824
R174 OUTN.n10 OUTN.t13 0.0824
R175 OUTN.n10 OUTN.t14 0.0824
R176 OUTN.n12 OUTN.t10 0.0824
R177 OUTN.n12 OUTN.t11 0.0824
R178 OUTN OUTN.n16 0.0647857
R179 OUTP.n0 OUTP.t1 15.8895
R180 OUTP.n2 OUTP.t0 15.4095
R181 OUTP.n1 OUTP.t2 15.4095
R182 OUTP.n0 OUTP.t8 15.4095
R183 OUTP.n3 OUTP.t9 15.4095
R184 OUTP.n4 OUTP.t14 7.86957
R185 OUTP.n11 OUTP.n10 7.78767
R186 OUTP.n14 OUTP.t7 7.77479
R187 OUTP.n8 OUTP.n5 7.69289
R188 OUTP.n7 OUTP.n6 7.69289
R189 OUTP.n13 OUTP.n12 7.69289
R190 OUTP.n15 OUTP.n14 4.5005
R191 OUTP.n9 OUTP.n8 4.5005
R192 OUTP.n15 OUTP.n11 2.38404
R193 OUTP.n9 OUTP.n4 2.38404
R194 OUTP.n1 OUTP.n0 0.4805
R195 OUTP.n2 OUTP.n1 0.4805
R196 OUTP.n3 OUTP.n2 0.413
R197 OUTP OUTP.n3 0.386214
R198 OUTP.n16 OUTP.n9 0.3695
R199 OUTP.n8 OUTP.n7 0.189974
R200 OUTP.n14 OUTP.n13 0.189974
R201 OUTP.n16 OUTP.n15 0.1175
R202 OUTP.n13 OUTP.n11 0.092352
R203 OUTP.n7 OUTP.n4 0.092352
R204 OUTP.n5 OUTP.t10 0.0824
R205 OUTP.n5 OUTP.t11 0.0824
R206 OUTP.n6 OUTP.t13 0.0824
R207 OUTP.n6 OUTP.t12 0.0824
R208 OUTP.n10 OUTP.t3 0.0824
R209 OUTP.n10 OUTP.t4 0.0824
R210 OUTP.n12 OUTP.t5 0.0824
R211 OUTP.n12 OUTP.t6 0.0824
R212 OUTP OUTP.n16 0.0647857
R213 LOAD_EN0_N.n6 LOAD_EN0_N.t4 270.06
R214 LOAD_EN0_N.n2 LOAD_EN0_N.t0 270.06
R215 LOAD_EN0_N.n10 LOAD_EN0_N.t5 270.06
R216 LOAD_EN0_N.n11 LOAD_EN0_N.t9 270.06
R217 LOAD_EN0_N.n5 LOAD_EN0_N.t3 265.603
R218 LOAD_EN0_N.n4 LOAD_EN0_N.t2 265.603
R219 LOAD_EN0_N.n3 LOAD_EN0_N.t1 265.603
R220 LOAD_EN0_N.n13 LOAD_EN0_N.t6 265.603
R221 LOAD_EN0_N.n14 LOAD_EN0_N.t7 265.603
R222 LOAD_EN0_N.n12 LOAD_EN0_N.t8 265.603
R223 LOAD_EN0_N.n4 LOAD_EN0_N.n1 18.4942
R224 LOAD_EN0_N.n15 LOAD_EN0_N.n14 18.4942
R225 LOAD_EN0_N.n5 LOAD_EN0_N.n4 11.6805
R226 LOAD_EN0_N.n4 LOAD_EN0_N.n3 11.6805
R227 LOAD_EN0_N.n14 LOAD_EN0_N.n13 11.6805
R228 LOAD_EN0_N.n14 LOAD_EN0_N.n12 11.6805
R229 LOAD_EN0_N.n7 LOAD_EN0_N.n6 7.12887
R230 LOAD_EN0_N.n2 LOAD_EN0_N.n0 7.12887
R231 LOAD_EN0_N.n11 LOAD_EN0_N.n9 7.12887
R232 LOAD_EN0_N.n16 LOAD_EN0_N.n10 7.12887
R233 LOAD_EN0_N.n8 LOAD_EN0_N.n0 4.5725
R234 LOAD_EN0_N.n17 LOAD_EN0_N.n9 4.5725
R235 LOAD_EN0_N.n8 LOAD_EN0_N.n7 4.5005
R236 LOAD_EN0_N.n17 LOAD_EN0_N.n16 4.5005
R237 LOAD_EN0_N.n6 LOAD_EN0_N.n5 4.42851
R238 LOAD_EN0_N.n3 LOAD_EN0_N.n2 4.42851
R239 LOAD_EN0_N.n13 LOAD_EN0_N.n10 4.42851
R240 LOAD_EN0_N.n12 LOAD_EN0_N.n11 4.42851
R241 LOAD_EN0_N LOAD_EN0_N.n8 1.14495
R242 LOAD_EN0_N LOAD_EN0_N.n17 1.02923
R243 LOAD_EN0_N.n7 LOAD_EN0_N.n1 0.0485
R244 LOAD_EN0_N.n1 LOAD_EN0_N.n0 0.0485
R245 LOAD_EN0_N.n15 LOAD_EN0_N.n9 0.0485
R246 LOAD_EN0_N.n16 LOAD_EN0_N.n15 0.0485
R247 LOAD_EN1_N.n3 LOAD_EN1_N.t4 270.06
R248 LOAD_EN1_N.n1 LOAD_EN1_N.t0 270.06
R249 LOAD_EN1_N.n10 LOAD_EN1_N.t5 270.06
R250 LOAD_EN1_N.n11 LOAD_EN1_N.t9 270.06
R251 LOAD_EN1_N.n4 LOAD_EN1_N.t3 265.603
R252 LOAD_EN1_N.n5 LOAD_EN1_N.t2 265.603
R253 LOAD_EN1_N.n2 LOAD_EN1_N.t1 265.603
R254 LOAD_EN1_N.n13 LOAD_EN1_N.t6 265.603
R255 LOAD_EN1_N.n14 LOAD_EN1_N.t7 265.603
R256 LOAD_EN1_N.n12 LOAD_EN1_N.t8 265.603
R257 LOAD_EN1_N.n6 LOAD_EN1_N.n5 18.4942
R258 LOAD_EN1_N.n15 LOAD_EN1_N.n14 18.4942
R259 LOAD_EN1_N.n5 LOAD_EN1_N.n4 11.6805
R260 LOAD_EN1_N.n5 LOAD_EN1_N.n2 11.6805
R261 LOAD_EN1_N.n14 LOAD_EN1_N.n13 11.6805
R262 LOAD_EN1_N.n14 LOAD_EN1_N.n12 11.6805
R263 LOAD_EN1_N.n3 LOAD_EN1_N.n0 7.12887
R264 LOAD_EN1_N.n7 LOAD_EN1_N.n1 7.12887
R265 LOAD_EN1_N.n11 LOAD_EN1_N.n9 7.12887
R266 LOAD_EN1_N.n16 LOAD_EN1_N.n10 7.12887
R267 LOAD_EN1_N LOAD_EN1_N.n8 5.50402
R268 LOAD_EN1_N.n8 LOAD_EN1_N.n7 4.537
R269 LOAD_EN1_N.n17 LOAD_EN1_N.n9 4.537
R270 LOAD_EN1_N.n8 LOAD_EN1_N.n0 4.53643
R271 LOAD_EN1_N.n17 LOAD_EN1_N.n16 4.53643
R272 LOAD_EN1_N.n4 LOAD_EN1_N.n3 4.42851
R273 LOAD_EN1_N.n2 LOAD_EN1_N.n1 4.42851
R274 LOAD_EN1_N.n13 LOAD_EN1_N.n10 4.42851
R275 LOAD_EN1_N.n12 LOAD_EN1_N.n11 4.42851
R276 LOAD_EN1_N LOAD_EN1_N.n17 2.81688
R277 LOAD_EN1_N.n6 LOAD_EN1_N.n0 0.0485
R278 LOAD_EN1_N.n7 LOAD_EN1_N.n6 0.0485
R279 LOAD_EN1_N.n15 LOAD_EN1_N.n9 0.0485
R280 LOAD_EN1_N.n16 LOAD_EN1_N.n15 0.0485
R281 LOAD_EN2_N.n6 LOAD_EN2_N.t4 270.06
R282 LOAD_EN2_N.n2 LOAD_EN2_N.t0 270.06
R283 LOAD_EN2_N.n10 LOAD_EN2_N.t5 270.06
R284 LOAD_EN2_N.n11 LOAD_EN2_N.t9 270.06
R285 LOAD_EN2_N.n5 LOAD_EN2_N.t3 265.603
R286 LOAD_EN2_N.n4 LOAD_EN2_N.t2 265.603
R287 LOAD_EN2_N.n3 LOAD_EN2_N.t1 265.603
R288 LOAD_EN2_N.n13 LOAD_EN2_N.t6 265.603
R289 LOAD_EN2_N.n14 LOAD_EN2_N.t7 265.603
R290 LOAD_EN2_N.n12 LOAD_EN2_N.t8 265.603
R291 LOAD_EN2_N.n4 LOAD_EN2_N.n1 18.4942
R292 LOAD_EN2_N.n15 LOAD_EN2_N.n14 18.4942
R293 LOAD_EN2_N.n5 LOAD_EN2_N.n4 11.6805
R294 LOAD_EN2_N.n4 LOAD_EN2_N.n3 11.6805
R295 LOAD_EN2_N.n14 LOAD_EN2_N.n13 11.6805
R296 LOAD_EN2_N.n14 LOAD_EN2_N.n12 11.6805
R297 LOAD_EN2_N LOAD_EN2_N.n17 8.46191
R298 LOAD_EN2_N.n7 LOAD_EN2_N.n6 7.12887
R299 LOAD_EN2_N.n2 LOAD_EN2_N.n0 7.12887
R300 LOAD_EN2_N.n11 LOAD_EN2_N.n9 7.12887
R301 LOAD_EN2_N.n16 LOAD_EN2_N.n10 7.12887
R302 LOAD_EN2_N LOAD_EN2_N.n8 6.0062
R303 LOAD_EN2_N.n8 LOAD_EN2_N.n0 4.53672
R304 LOAD_EN2_N.n17 LOAD_EN2_N.n9 4.53672
R305 LOAD_EN2_N.n8 LOAD_EN2_N.n7 4.53671
R306 LOAD_EN2_N.n17 LOAD_EN2_N.n16 4.53671
R307 LOAD_EN2_N.n6 LOAD_EN2_N.n5 4.42851
R308 LOAD_EN2_N.n3 LOAD_EN2_N.n2 4.42851
R309 LOAD_EN2_N.n13 LOAD_EN2_N.n10 4.42851
R310 LOAD_EN2_N.n12 LOAD_EN2_N.n11 4.42851
R311 LOAD_EN2_N.n7 LOAD_EN2_N.n1 0.0485
R312 LOAD_EN2_N.n1 LOAD_EN2_N.n0 0.0485
R313 LOAD_EN2_N.n15 LOAD_EN2_N.n9 0.0485
R314 LOAD_EN2_N.n16 LOAD_EN2_N.n15 0.0485
R315 LOAD_EN3_N.n3 LOAD_EN3_N.t4 270.06
R316 LOAD_EN3_N.n1 LOAD_EN3_N.t0 270.06
R317 LOAD_EN3_N.n10 LOAD_EN3_N.t5 270.06
R318 LOAD_EN3_N.n11 LOAD_EN3_N.t9 270.06
R319 LOAD_EN3_N.n4 LOAD_EN3_N.t3 265.603
R320 LOAD_EN3_N.n5 LOAD_EN3_N.t2 265.603
R321 LOAD_EN3_N.n2 LOAD_EN3_N.t1 265.603
R322 LOAD_EN3_N.n13 LOAD_EN3_N.t6 265.603
R323 LOAD_EN3_N.n14 LOAD_EN3_N.t7 265.603
R324 LOAD_EN3_N.n12 LOAD_EN3_N.t8 265.603
R325 LOAD_EN3_N.n6 LOAD_EN3_N.n5 18.4942
R326 LOAD_EN3_N.n15 LOAD_EN3_N.n14 18.4942
R327 LOAD_EN3_N.n5 LOAD_EN3_N.n4 11.6805
R328 LOAD_EN3_N.n5 LOAD_EN3_N.n2 11.6805
R329 LOAD_EN3_N.n14 LOAD_EN3_N.n13 11.6805
R330 LOAD_EN3_N.n14 LOAD_EN3_N.n12 11.6805
R331 LOAD_EN3_N LOAD_EN3_N.n8 9.60554
R332 LOAD_EN3_N.n3 LOAD_EN3_N.n0 7.12887
R333 LOAD_EN3_N.n7 LOAD_EN3_N.n1 7.12887
R334 LOAD_EN3_N.n11 LOAD_EN3_N.n9 7.12887
R335 LOAD_EN3_N.n16 LOAD_EN3_N.n10 7.12887
R336 LOAD_EN3_N LOAD_EN3_N.n17 7.03983
R337 LOAD_EN3_N.n8 LOAD_EN3_N.n7 4.53672
R338 LOAD_EN3_N.n17 LOAD_EN3_N.n9 4.53672
R339 LOAD_EN3_N.n8 LOAD_EN3_N.n0 4.53672
R340 LOAD_EN3_N.n17 LOAD_EN3_N.n16 4.53672
R341 LOAD_EN3_N.n4 LOAD_EN3_N.n3 4.42851
R342 LOAD_EN3_N.n2 LOAD_EN3_N.n1 4.42851
R343 LOAD_EN3_N.n13 LOAD_EN3_N.n10 4.42851
R344 LOAD_EN3_N.n12 LOAD_EN3_N.n11 4.42851
R345 LOAD_EN3_N.n6 LOAD_EN3_N.n0 0.0485
R346 LOAD_EN3_N.n7 LOAD_EN3_N.n6 0.0485
R347 LOAD_EN3_N.n15 LOAD_EN3_N.n9 0.0485
R348 LOAD_EN3_N.n16 LOAD_EN3_N.n15 0.0485
R349 VDD.n47 VDD.t72 102.249
R350 VDD.t68 VDD.n49 102.249
R351 VDD.t38 VDD.n15 93.7391
R352 VDD.n64 VDD.t20 93.7391
R353 VDD.n35 VDD.t80 68.0856
R354 VDD.n35 VDD.t43 68.0856
R355 VDD.t59 VDD.n34 68.0856
R356 VDD.n34 VDD.t10 68.0856
R357 VDD.n16 VDD.t18 68.0856
R358 VDD.n16 VDD.t30 68.0856
R359 VDD.t28 VDD.n60 68.0856
R360 VDD.n60 VDD.t0 68.0856
R361 VDD.t8 VDD.n59 68.0856
R362 VDD.n59 VDD.t45 68.0856
R363 VDD.t51 VDD.n50 68.0856
R364 VDD.n50 VDD.t62 68.0856
R365 VDD.t74 VDD.t72 34.0431
R366 VDD.t76 VDD.t74 34.0431
R367 VDD.t78 VDD.t76 34.0431
R368 VDD.t80 VDD.t78 34.0431
R369 VDD.t43 VDD.t55 34.0431
R370 VDD.t55 VDD.t57 34.0431
R371 VDD.t57 VDD.t53 34.0431
R372 VDD.t53 VDD.t59 34.0431
R373 VDD.t12 VDD.t10 34.0431
R374 VDD.t14 VDD.t12 34.0431
R375 VDD.t16 VDD.t14 34.0431
R376 VDD.t18 VDD.t16 34.0431
R377 VDD.t30 VDD.t32 34.0431
R378 VDD.t32 VDD.t36 34.0431
R379 VDD.t36 VDD.t34 34.0431
R380 VDD.t34 VDD.t38 34.0431
R381 VDD.t20 VDD.t22 34.0431
R382 VDD.t22 VDD.t24 34.0431
R383 VDD.t24 VDD.t26 34.0431
R384 VDD.t26 VDD.t28 34.0431
R385 VDD.t0 VDD.t2 34.0431
R386 VDD.t2 VDD.t4 34.0431
R387 VDD.t4 VDD.t6 34.0431
R388 VDD.t6 VDD.t8 34.0431
R389 VDD.t45 VDD.t41 34.0431
R390 VDD.t41 VDD.t47 34.0431
R391 VDD.t47 VDD.t49 34.0431
R392 VDD.t49 VDD.t51 34.0431
R393 VDD.t62 VDD.t64 34.0431
R394 VDD.t64 VDD.t66 34.0431
R395 VDD.t66 VDD.t70 34.0431
R396 VDD.t70 VDD.t68 34.0431
R397 VDD.n11 VDD.t61 17.5656
R398 VDD.n65 VDD.t40 17.5656
R399 VDD.n20 VDD.n16 17.1434
R400 VDD.n34 VDD.n33 17.1434
R401 VDD.n37 VDD.n35 17.1434
R402 VDD.n84 VDD.n50 17.1434
R403 VDD.n59 VDD.n58 17.1434
R404 VDD.n72 VDD.n60 17.1434
R405 VDD.n14 VDD.t39 7.7577
R406 VDD.n19 VDD.t19 7.7577
R407 VDD.n32 VDD.t60 7.7577
R408 VDD.n36 VDD.t81 7.7577
R409 VDD.n48 VDD.t69 7.7577
R410 VDD.n83 VDD.t52 7.7577
R411 VDD.n57 VDD.t9 7.7577
R412 VDD.n71 VDD.t29 7.7577
R413 VDD.n13 VDD.n12 7.6667
R414 VDD.n22 VDD.n21 7.6667
R415 VDD.n18 VDD.n17 7.6667
R416 VDD.n29 VDD.n28 7.6667
R417 VDD.n31 VDD.n30 7.6667
R418 VDD.n39 VDD.n38 7.6667
R419 VDD.n5 VDD.n4 7.6667
R420 VDD.n46 VDD.n45 7.6667
R421 VDD.n3 VDD.n2 7.6667
R422 VDD.n86 VDD.n85 7.6667
R423 VDD.n82 VDD.n81 7.6667
R424 VDD.n56 VDD.n55 7.6667
R425 VDD.n54 VDD.n53 7.6667
R426 VDD.n74 VDD.n73 7.6667
R427 VDD.n70 VDD.n69 7.6667
R428 VDD.n63 VDD.n62 7.6667
R429 VDD.n65 VDD.n64 4.7255
R430 VDD.n15 VDD.n11 4.7255
R431 VDD.n68 VDD.n67 4.5005
R432 VDD.n66 VDD.n61 4.5005
R433 VDD.n75 VDD.n52 4.5005
R434 VDD.n77 VDD.n76 4.5005
R435 VDD.n78 VDD.n51 4.5005
R436 VDD.n80 VDD.n79 4.5005
R437 VDD.n87 VDD.n1 4.5005
R438 VDD.n89 VDD.n88 4.5005
R439 VDD.n44 VDD.n0 4.5005
R440 VDD.n43 VDD.n42 4.5005
R441 VDD.n41 VDD.n40 4.5005
R442 VDD.n7 VDD.n6 4.5005
R443 VDD.n27 VDD.n26 4.5005
R444 VDD.n25 VDD.n8 4.5005
R445 VDD.n24 VDD.n23 4.5005
R446 VDD.n10 VDD.n9 4.5005
R447 VDD.n49 VDD.n47 0.7805
R448 VDD VDD.n0 0.7115
R449 VDD VDD.n89 0.5615
R450 VDD.n67 VDD.n52 0.4325
R451 VDD.n78 VDD.n77 0.4325
R452 VDD.n79 VDD.n1 0.4325
R453 VDD.n42 VDD.n41 0.4325
R454 VDD.n26 VDD.n6 0.4325
R455 VDD.n25 VDD.n24 0.4325
R456 VDD.n66 VDD.n65 0.404
R457 VDD.n11 VDD.n9 0.404
R458 VDD.n47 VDD.n46 0.1805
R459 VDD.n64 VDD.n63 0.1655
R460 VDD.n74 VDD.n72 0.1505
R461 VDD.n58 VDD.n56 0.1505
R462 VDD.n86 VDD.n84 0.1505
R463 VDD.n39 VDD.n37 0.1505
R464 VDD.n33 VDD.n29 0.1505
R465 VDD.n22 VDD.n20 0.1505
R466 VDD.n71 VDD.n70 0.1205
R467 VDD.n57 VDD.n54 0.1205
R468 VDD.n83 VDD.n82 0.1205
R469 VDD.n48 VDD.n3 0.1205
R470 VDD.n49 VDD.n48 0.1205
R471 VDD.n36 VDD.n5 0.1205
R472 VDD.n32 VDD.n31 0.1205
R473 VDD.n19 VDD.n18 0.1205
R474 VDD.n14 VDD.n13 0.1205
R475 VDD.n15 VDD.n14 0.1055
R476 VDD.n12 VDD.t37 0.0915
R477 VDD.n12 VDD.t35 0.0915
R478 VDD.n21 VDD.t31 0.0915
R479 VDD.n21 VDD.t33 0.0915
R480 VDD.n17 VDD.t15 0.0915
R481 VDD.n17 VDD.t17 0.0915
R482 VDD.n28 VDD.t11 0.0915
R483 VDD.n28 VDD.t13 0.0915
R484 VDD.n30 VDD.t58 0.0915
R485 VDD.n30 VDD.t54 0.0915
R486 VDD.n38 VDD.t44 0.0915
R487 VDD.n38 VDD.t56 0.0915
R488 VDD.n4 VDD.t77 0.0915
R489 VDD.n4 VDD.t79 0.0915
R490 VDD.n45 VDD.t73 0.0915
R491 VDD.n45 VDD.t75 0.0915
R492 VDD.n2 VDD.t67 0.0915
R493 VDD.n2 VDD.t71 0.0915
R494 VDD.n85 VDD.t63 0.0915
R495 VDD.n85 VDD.t65 0.0915
R496 VDD.n81 VDD.t48 0.0915
R497 VDD.n81 VDD.t50 0.0915
R498 VDD.n55 VDD.t46 0.0915
R499 VDD.n55 VDD.t42 0.0915
R500 VDD.n53 VDD.t5 0.0915
R501 VDD.n53 VDD.t7 0.0915
R502 VDD.n73 VDD.t1 0.0915
R503 VDD.n73 VDD.t3 0.0915
R504 VDD.n69 VDD.t25 0.0915
R505 VDD.n69 VDD.t27 0.0915
R506 VDD.n62 VDD.t21 0.0915
R507 VDD.n62 VDD.t23 0.0915
R508 VDD.n72 VDD.n71 0.0905
R509 VDD.n58 VDD.n57 0.0905
R510 VDD.n84 VDD.n83 0.0905
R511 VDD.n37 VDD.n36 0.0905
R512 VDD.n33 VDD.n32 0.0905
R513 VDD.n20 VDD.n19 0.0905
R514 VDD.n63 VDD.n61 0.0665
R515 VDD.n75 VDD.n74 0.0665
R516 VDD.n56 VDD.n51 0.0665
R517 VDD.n87 VDD.n86 0.0665
R518 VDD.n46 VDD.n44 0.0665
R519 VDD.n40 VDD.n39 0.0665
R520 VDD.n29 VDD.n27 0.0665
R521 VDD.n23 VDD.n22 0.0665
R522 VDD.n67 VDD.n66 0.0485
R523 VDD.n77 VDD.n52 0.0485
R524 VDD.n79 VDD.n78 0.0485
R525 VDD.n89 VDD.n1 0.0485
R526 VDD.n42 VDD.n0 0.0485
R527 VDD.n41 VDD.n6 0.0485
R528 VDD.n26 VDD.n25 0.0485
R529 VDD.n24 VDD.n9 0.0485
R530 VDD.n68 VDD.n61 0.0485
R531 VDD.n76 VDD.n75 0.0485
R532 VDD.n80 VDD.n51 0.0485
R533 VDD.n88 VDD.n87 0.0485
R534 VDD.n44 VDD.n43 0.0485
R535 VDD.n40 VDD.n7 0.0485
R536 VDD.n27 VDD.n8 0.0485
R537 VDD.n23 VDD.n10 0.0485
R538 VDD.n70 VDD.n68 0.0065
R539 VDD.n76 VDD.n54 0.0065
R540 VDD.n82 VDD.n80 0.0065
R541 VDD.n88 VDD.n3 0.0065
R542 VDD.n43 VDD.n5 0.0065
R543 VDD.n31 VDD.n7 0.0065
R544 VDD.n18 VDD.n8 0.0065
R545 VDD.n13 VDD.n10 0.0065
R546 VSS.n99 VSS.t7 158.066
R547 VSS.n20 VSS.t46 158.066
R548 VSS.n100 VSS.n99 134.881
R549 VSS.n21 VSS.n20 134.881
R550 VSS.t48 VSS.n150 117.553
R551 VSS.n70 VSS.t57 117.553
R552 VSS.n149 VSS.n96 50.7505
R553 VSS.n71 VSS.n15 50.7505
R554 VSS.n153 VSS.t52 48.4048
R555 VSS.n76 VSS.t53 48.4048
R556 VSS.t10 VSS.n95 44.2558
R557 VSS.t8 VSS.n16 44.2558
R558 VSS.n61 VSS.n17 42.0005
R559 VSS.n117 VSS.n94 42.0005
R560 VSS.t26 VSS.t24 35.2665
R561 VSS.t28 VSS.t26 35.2665
R562 VSS.t32 VSS.t30 35.2665
R563 VSS.t34 VSS.t32 35.2665
R564 VSS.n41 VSS.n19 35.0005
R565 VSS.n45 VSS.n44 35.0005
R566 VSS.n49 VSS.n48 35.0005
R567 VSS.n51 VSS.n25 35.0005
R568 VSS.n54 VSS.n25 35.0005
R569 VSS.n58 VSS.n31 35.0005
R570 VSS.n58 VSS.n30 35.0005
R571 VSS.n38 VSS.n37 35.0005
R572 VSS.n34 VSS.n33 35.0005
R573 VSS.n113 VSS.n94 35.0005
R574 VSS.n113 VSS.n92 35.0005
R575 VSS.n92 VSS.n6 35.0005
R576 VSS.n160 VSS.n6 35.0005
R577 VSS.n160 VSS.n4 35.0005
R578 VSS.n81 VSS.n4 35.0005
R579 VSS.n81 VSS.n80 35.0005
R580 VSS.n80 VSS.n11 35.0005
R581 VSS.n66 VSS.n11 35.0005
R582 VSS.n66 VSS.n17 35.0005
R583 VSS.n121 VSS.n111 35.0005
R584 VSS.n124 VSS.n123 35.0005
R585 VSS.n128 VSS.n108 35.0005
R586 VSS.n131 VSS.n130 35.0005
R587 VSS.n135 VSS.n105 35.0005
R588 VSS.n138 VSS.n137 35.0005
R589 VSS.n142 VSS.n102 35.0005
R590 VSS.n145 VSS.n144 35.0005
R591 VSS.n149 VSS.n88 35.0005
R592 VSS.n154 VSS.n88 35.0005
R593 VSS.n154 VSS.n8 35.0005
R594 VSS.n158 VSS.n8 35.0005
R595 VSS.n158 VSS.n7 35.0005
R596 VSS.n84 VSS.n7 35.0005
R597 VSS.n84 VSS.n10 35.0005
R598 VSS.n75 VSS.n10 35.0005
R599 VSS.n75 VSS.n13 35.0005
R600 VSS.n71 VSS.n13 35.0005
R601 VSS.n101 VSS.t10 34.575
R602 VSS.n59 VSS.t8 34.575
R603 VSS.n90 VSS.t18 30.7718
R604 VSS.n78 VSS.t42 30.7718
R605 VSS.t24 VSS.t15 29.3888
R606 VSS.t1 VSS.t34 29.3888
R607 VSS.t50 VSS.t51 27.6601
R608 VSS.t63 VSS.t64 27.6601
R609 VSS.t66 VSS.t65 27.6601
R610 VSS.t11 VSS.t12 27.6601
R611 VSS.t5 VSS.t4 27.6601
R612 VSS.t60 VSS.t59 27.6601
R613 VSS.t61 VSS.t62 27.6601
R614 VSS.t54 VSS.t55 27.6601
R615 VSS.t64 VSS.n91 24.8941
R616 VSS.n77 VSS.t61 24.8941
R617 VSS.t22 VSS.t13 21.0909
R618 VSS.t40 VSS.t3 21.0909
R619 VSS.n99 VSS.t45 21.0713
R620 VSS.n20 VSS.t0 21.0713
R621 VSS.t49 VSS.t6 20.7452
R622 VSS.t44 VSS.t56 20.7452
R623 VSS.t52 VSS.n152 17.9792
R624 VSS.n68 VSS.t53 17.9792
R625 VSS.n82 VSS.t28 17.6335
R626 VSS.t30 VSS.n82 17.6335
R627 VSS.n151 VSS.n93 16.5962
R628 VSS.n90 VSS.n89 16.5962
R629 VSS.n79 VSS.n78 16.5962
R630 VSS.n69 VSS.n67 16.5962
R631 VSS.n159 VSS.t20 14.8675
R632 VSS.n83 VSS.t36 14.8675
R633 VSS.t13 VSS.t16 14.176
R634 VSS.t3 VSS.t38 14.176
R635 VSS.n153 VSS.t63 13.8303
R636 VSS.t47 VSS.t66 13.8303
R637 VSS.t67 VSS.t47 13.8303
R638 VSS.n89 VSS.t67 13.8303
R639 VSS.n79 VSS.t58 13.8303
R640 VSS.t9 VSS.t58 13.8303
R641 VSS.t59 VSS.t9 13.8303
R642 VSS.t62 VSS.n76 13.8303
R643 VSS.t16 VSS.t14 13.4845
R644 VSS.t38 VSS.t2 13.4845
R645 VSS.n150 VSS.n95 11.0643
R646 VSS.n70 VSS.n16 11.0643
R647 VSS.n101 VSS.n100 9.68135
R648 VSS.n152 VSS.t51 9.68135
R649 VSS.n68 VSS.t54 9.68135
R650 VSS.n59 VSS.n21 9.68135
R651 VSS.n164 VSS.n163 7.69289
R652 VSS.n166 VSS.n165 7.69289
R653 VSS.n168 VSS.n167 7.69289
R654 VSS.n170 VSS.n169 7.69289
R655 VSS.n174 VSS.n171 7.69289
R656 VSS.n173 VSS.n172 7.69289
R657 VSS.n2 VSS.n1 7.69289
R658 VSS.n93 VSS.t49 6.91539
R659 VSS.t6 VSS.t50 6.91539
R660 VSS.n159 VSS.t14 6.91539
R661 VSS.n83 VSS.t2 6.91539
R662 VSS.t55 VSS.t44 6.91539
R663 VSS.t56 VSS.n67 6.91539
R664 VSS.t12 VSS.t22 6.56965
R665 VSS.t4 VSS.t40 6.56965
R666 VSS.t15 VSS.t20 5.87816
R667 VSS.t36 VSS.t1 5.87816
R668 VSS.n70 VSS.n17 5.2005
R669 VSS.n63 VSS.n17 5.2005
R670 VSS.n67 VSS.n66 5.2005
R671 VSS.n66 VSS.n65 5.2005
R672 VSS.n76 VSS.n11 5.2005
R673 VSS.n64 VSS.n11 5.2005
R674 VSS.n80 VSS.n79 5.2005
R675 VSS.n80 VSS.n12 5.2005
R676 VSS.n83 VSS.n81 5.2005
R677 VSS.n81 VSS.n3 5.2005
R678 VSS.n82 VSS.n4 5.2005
R679 VSS.n162 VSS.n4 5.2005
R680 VSS.n160 VSS.n159 5.2005
R681 VSS.n161 VSS.n160 5.2005
R682 VSS.n89 VSS.n6 5.2005
R683 VSS.n6 VSS.n5 5.2005
R684 VSS.n153 VSS.n92 5.2005
R685 VSS.n112 VSS.n92 5.2005
R686 VSS.n113 VSS.n93 5.2005
R687 VSS.n114 VSS.n113 5.2005
R688 VSS.n150 VSS.n94 5.2005
R689 VSS.n115 VSS.n94 5.2005
R690 VSS.n147 VSS.n96 5.2005
R691 VSS.n146 VSS.n145 5.2005
R692 VSS.n144 VSS.n97 5.2005
R693 VSS.n142 VSS.n141 5.2005
R694 VSS.n140 VSS.n102 5.2005
R695 VSS.n139 VSS.n138 5.2005
R696 VSS.n137 VSS.n103 5.2005
R697 VSS.n135 VSS.n134 5.2005
R698 VSS.n133 VSS.n105 5.2005
R699 VSS.n132 VSS.n131 5.2005
R700 VSS.n130 VSS.n106 5.2005
R701 VSS.n128 VSS.n127 5.2005
R702 VSS.n126 VSS.n108 5.2005
R703 VSS.n125 VSS.n124 5.2005
R704 VSS.n123 VSS.n109 5.2005
R705 VSS.n121 VSS.n120 5.2005
R706 VSS.n119 VSS.n111 5.2005
R707 VSS.n118 VSS.n117 5.2005
R708 VSS.n71 VSS.n70 5.2005
R709 VSS.n72 VSS.n71 5.2005
R710 VSS.n67 VSS.n13 5.2005
R711 VSS.n73 VSS.n13 5.2005
R712 VSS.n76 VSS.n75 5.2005
R713 VSS.n75 VSS.n74 5.2005
R714 VSS.n79 VSS.n10 5.2005
R715 VSS.n10 VSS.n9 5.2005
R716 VSS.n84 VSS.n83 5.2005
R717 VSS.n85 VSS.n84 5.2005
R718 VSS.n82 VSS.n7 5.2005
R719 VSS.n86 VSS.n7 5.2005
R720 VSS.n159 VSS.n158 5.2005
R721 VSS.n158 VSS.n157 5.2005
R722 VSS.n89 VSS.n8 5.2005
R723 VSS.n156 VSS.n8 5.2005
R724 VSS.n154 VSS.n153 5.2005
R725 VSS.n155 VSS.n154 5.2005
R726 VSS.n93 VSS.n88 5.2005
R727 VSS.n88 VSS.n87 5.2005
R728 VSS.n150 VSS.n149 5.2005
R729 VSS.n149 VSS.n148 5.2005
R730 VSS.n62 VSS.n61 5.2005
R731 VSS.n19 VSS.n18 5.2005
R732 VSS.n42 VSS.n41 5.2005
R733 VSS.n44 VSS.n43 5.2005
R734 VSS.n46 VSS.n45 5.2005
R735 VSS.n48 VSS.n47 5.2005
R736 VSS.n50 VSS.n49 5.2005
R737 VSS.n52 VSS.n51 5.2005
R738 VSS.n59 VSS.n25 5.2005
R739 VSS.n53 VSS.n25 5.2005
R740 VSS.n55 VSS.n54 5.2005
R741 VSS.n56 VSS.n31 5.2005
R742 VSS.n59 VSS.n58 5.2005
R743 VSS.n58 VSS.n57 5.2005
R744 VSS.n40 VSS.n30 5.2005
R745 VSS.n39 VSS.n38 5.2005
R746 VSS.n37 VSS.n36 5.2005
R747 VSS.n35 VSS.n34 5.2005
R748 VSS.n33 VSS.n32 5.2005
R749 VSS.n15 VSS.n14 5.2005
R750 VSS.n170 VSS.n162 4.8755
R751 VSS.n175 VSS.n2 4.8065
R752 VSS.n164 VSS.n0 4.8065
R753 VSS.n175 VSS.n174 4.5005
R754 VSS.n168 VSS.n0 4.5005
R755 VSS.n21 VSS.n16 4.44204
R756 VSS.n69 VSS.n68 4.44204
R757 VSS.n78 VSS.n77 4.44204
R758 VSS.n91 VSS.n90 4.44204
R759 VSS.n152 VSS.n151 4.44204
R760 VSS.n100 VSS.n95 4.44204
R761 VSS.n151 VSS.t48 4.14944
R762 VSS.t57 VSS.n69 4.14944
R763 VSS.n98 VSS.n96 4.00981
R764 VSS.n144 VSS.n143 4.00981
R765 VSS.n104 VSS.n102 4.00981
R766 VSS.n137 VSS.n136 4.00981
R767 VSS.n107 VSS.n105 4.00981
R768 VSS.n130 VSS.n129 4.00981
R769 VSS.n110 VSS.n108 4.00981
R770 VSS.n123 VSS.n122 4.00981
R771 VSS.n116 VSS.n111 4.00981
R772 VSS.n61 VSS.n60 4.00981
R773 VSS.n44 VSS.n28 4.00981
R774 VSS.n48 VSS.n27 4.00981
R775 VSS.n51 VSS.n26 4.00981
R776 VSS.n31 VSS.n29 4.00981
R777 VSS.n38 VSS.n24 4.00981
R778 VSS.n34 VSS.n23 4.00981
R779 VSS.n22 VSS.n15 4.00981
R780 VSS.n60 VSS.n19 4.00981
R781 VSS.n41 VSS.n28 4.00981
R782 VSS.n45 VSS.n27 4.00981
R783 VSS.n49 VSS.n26 4.00981
R784 VSS.n54 VSS.n29 4.00981
R785 VSS.n30 VSS.n24 4.00981
R786 VSS.n37 VSS.n23 4.00981
R787 VSS.n33 VSS.n22 4.00981
R788 VSS.n117 VSS.n116 4.00981
R789 VSS.n122 VSS.n121 4.00981
R790 VSS.n124 VSS.n110 4.00981
R791 VSS.n129 VSS.n128 4.00981
R792 VSS.n131 VSS.n107 4.00981
R793 VSS.n136 VSS.n135 4.00981
R794 VSS.n138 VSS.n104 4.00981
R795 VSS.n143 VSS.n142 4.00981
R796 VSS.n145 VSS.n98 4.00981
R797 VSS.n91 VSS.t65 2.76646
R798 VSS.n77 VSS.t60 2.76646
R799 VSS.t18 VSS.t11 1.03773
R800 VSS.t42 VSS.t5 1.03773
R801 VSS.n148 VSS.n147 0.653
R802 VSS.n72 VSS.n14 0.653
R803 VSS.n101 VSS.n98 0.596595
R804 VSS.n143 VSS.n101 0.596595
R805 VSS.n104 VSS.n101 0.596595
R806 VSS.n136 VSS.n101 0.596595
R807 VSS.n107 VSS.n101 0.596595
R808 VSS.n129 VSS.n101 0.596595
R809 VSS.n110 VSS.n101 0.596595
R810 VSS.n122 VSS.n101 0.596595
R811 VSS.n116 VSS.n101 0.596595
R812 VSS.n60 VSS.n59 0.596595
R813 VSS.n59 VSS.n28 0.596595
R814 VSS.n59 VSS.n27 0.596595
R815 VSS.n59 VSS.n26 0.596595
R816 VSS.n59 VSS.n29 0.596595
R817 VSS.n59 VSS.n24 0.596595
R818 VSS.n59 VSS.n23 0.596595
R819 VSS.n59 VSS.n22 0.596595
R820 VSS.n118 VSS.n115 0.5405
R821 VSS.n63 VSS.n62 0.5405
R822 VSS.n115 VSS.n114 0.4505
R823 VSS.n114 VSS.n112 0.4505
R824 VSS.n112 VSS.n5 0.4505
R825 VSS.n161 VSS.n5 0.4505
R826 VSS.n162 VSS.n161 0.4505
R827 VSS.n162 VSS.n3 0.4505
R828 VSS.n12 VSS.n3 0.4505
R829 VSS.n64 VSS.n12 0.4505
R830 VSS.n65 VSS.n64 0.4505
R831 VSS.n65 VSS.n63 0.4505
R832 VSS.n119 VSS.n118 0.4505
R833 VSS.n120 VSS.n119 0.4505
R834 VSS.n120 VSS.n109 0.4505
R835 VSS.n125 VSS.n109 0.4505
R836 VSS.n126 VSS.n125 0.4505
R837 VSS.n127 VSS.n126 0.4505
R838 VSS.n127 VSS.n106 0.4505
R839 VSS.n132 VSS.n106 0.4505
R840 VSS.n133 VSS.n132 0.4505
R841 VSS.n134 VSS.n133 0.4505
R842 VSS.n134 VSS.n103 0.4505
R843 VSS.n139 VSS.n103 0.4505
R844 VSS.n140 VSS.n139 0.4505
R845 VSS.n141 VSS.n140 0.4505
R846 VSS.n141 VSS.n97 0.4505
R847 VSS.n146 VSS.n97 0.4505
R848 VSS.n147 VSS.n146 0.4505
R849 VSS.n148 VSS.n87 0.4505
R850 VSS.n155 VSS.n87 0.4505
R851 VSS.n156 VSS.n155 0.4505
R852 VSS.n157 VSS.n156 0.4505
R853 VSS.n157 VSS.n86 0.4505
R854 VSS.n86 VSS.n85 0.4505
R855 VSS.n85 VSS.n9 0.4505
R856 VSS.n74 VSS.n9 0.4505
R857 VSS.n74 VSS.n73 0.4505
R858 VSS.n73 VSS.n72 0.4505
R859 VSS.n62 VSS.n18 0.4505
R860 VSS.n42 VSS.n18 0.4505
R861 VSS.n43 VSS.n42 0.4505
R862 VSS.n46 VSS.n43 0.4505
R863 VSS.n47 VSS.n46 0.4505
R864 VSS.n50 VSS.n47 0.4505
R865 VSS.n52 VSS.n50 0.4505
R866 VSS.n53 VSS.n52 0.4505
R867 VSS.n55 VSS.n53 0.4505
R868 VSS.n56 VSS.n55 0.4505
R869 VSS.n57 VSS.n56 0.4505
R870 VSS.n57 VSS.n40 0.4505
R871 VSS.n40 VSS.n39 0.4505
R872 VSS.n39 VSS.n36 0.4505
R873 VSS.n36 VSS.n35 0.4505
R874 VSS.n35 VSS.n32 0.4505
R875 VSS.n32 VSS.n14 0.4505
R876 VSS VSS.n0 0.2285
R877 VSS.n173 VSS.n2 0.1535
R878 VSS.n174 VSS.n173 0.1535
R879 VSS.n174 VSS.n170 0.1535
R880 VSS.n170 VSS.n168 0.1535
R881 VSS.n168 VSS.n166 0.1535
R882 VSS.n166 VSS.n164 0.1535
R883 VSS.n163 VSS.t41 0.0824
R884 VSS.n163 VSS.t43 0.0824
R885 VSS.n165 VSS.t37 0.0824
R886 VSS.n165 VSS.t39 0.0824
R887 VSS.n167 VSS.t33 0.0824
R888 VSS.n167 VSS.t35 0.0824
R889 VSS.n169 VSS.t29 0.0824
R890 VSS.n169 VSS.t31 0.0824
R891 VSS.n171 VSS.t25 0.0824
R892 VSS.n171 VSS.t27 0.0824
R893 VSS.n172 VSS.t17 0.0824
R894 VSS.n172 VSS.t21 0.0824
R895 VSS.n1 VSS.t19 0.0824
R896 VSS.n1 VSS.t23 0.0824
R897 VSS VSS.n175 0.0785
R898 a_n2292_n6800.n20 a_n2292_n6800.t0 8.01637
R899 a_n2292_n6800.n11 a_n2292_n6800.t14 7.85367
R900 a_n2292_n6800.t13 a_n2292_n6800.n28 7.77479
R901 a_n2292_n6800.n6 a_n2292_n6800.n5 7.77177
R902 a_n2292_n6800.n9 a_n2292_n6800.t19 7.75914
R903 a_n2292_n6800.n27 a_n2292_n6800.n26 7.69289
R904 a_n2292_n6800.n25 a_n2292_n6800.n1 7.69289
R905 a_n2292_n6800.n24 a_n2292_n6800.n23 7.69289
R906 a_n2292_n6800.n22 a_n2292_n6800.n2 7.69289
R907 a_n2292_n6800.n4 a_n2292_n6800.n3 7.69289
R908 a_n2292_n6800.n20 a_n2292_n6800.n19 7.69289
R909 a_n2292_n6800.n8 a_n2292_n6800.n7 7.67724
R910 a_n2292_n6800.n13 a_n2292_n6800.n12 7.67724
R911 a_n2292_n6800.n15 a_n2292_n6800.n14 7.67724
R912 a_n2292_n6800.n28 a_n2292_n6800.n0 4.8065
R913 a_n2292_n6800.n21 a_n2292_n6800.n20 4.8065
R914 a_n2292_n6800.n22 a_n2292_n6800.n21 4.5005
R915 a_n2292_n6800.n25 a_n2292_n6800.n0 4.5005
R916 a_n2292_n6800.n16 a_n2292_n6800.n15 4.5005
R917 a_n2292_n6800.n10 a_n2292_n6800.n9 4.5005
R918 a_n2292_n6800.n16 a_n2292_n6800.n11 2.35421
R919 a_n2292_n6800.n10 a_n2292_n6800.n6 2.35421
R920 a_n2292_n6800.n17 a_n2292_n6800.n16 0.608
R921 a_n2292_n6800.n17 a_n2292_n6800.n10 0.548
R922 a_n2292_n6800.n18 a_n2292_n6800.n17 0.514786
R923 a_n2292_n6800.n20 a_n2292_n6800.n4 0.242079
R924 a_n2292_n6800.n22 a_n2292_n6800.n4 0.242079
R925 a_n2292_n6800.n24 a_n2292_n6800.n22 0.242079
R926 a_n2292_n6800.n25 a_n2292_n6800.n24 0.242079
R927 a_n2292_n6800.n27 a_n2292_n6800.n25 0.242079
R928 a_n2292_n6800.n28 a_n2292_n6800.n27 0.242079
R929 a_n2292_n6800.n9 a_n2292_n6800.n8 0.189974
R930 a_n2292_n6800.n15 a_n2292_n6800.n13 0.189974
R931 a_n2292_n6800.n18 a_n2292_n6800.n0 0.1775
R932 a_n2292_n6800.n13 a_n2292_n6800.n11 0.0925875
R933 a_n2292_n6800.n8 a_n2292_n6800.n6 0.0925875
R934 a_n2292_n6800.n26 a_n2292_n6800.t11 0.0824
R935 a_n2292_n6800.n26 a_n2292_n6800.t12 0.0824
R936 a_n2292_n6800.n1 a_n2292_n6800.t9 0.0824
R937 a_n2292_n6800.n1 a_n2292_n6800.t10 0.0824
R938 a_n2292_n6800.n23 a_n2292_n6800.t7 0.0824
R939 a_n2292_n6800.n23 a_n2292_n6800.t8 0.0824
R940 a_n2292_n6800.n2 a_n2292_n6800.t5 0.0824
R941 a_n2292_n6800.n2 a_n2292_n6800.t6 0.0824
R942 a_n2292_n6800.n3 a_n2292_n6800.t3 0.0824
R943 a_n2292_n6800.n3 a_n2292_n6800.t4 0.0824
R944 a_n2292_n6800.n7 a_n2292_n6800.t20 0.0824
R945 a_n2292_n6800.n7 a_n2292_n6800.t21 0.0824
R946 a_n2292_n6800.n5 a_n2292_n6800.t22 0.0824
R947 a_n2292_n6800.n5 a_n2292_n6800.t23 0.0824
R948 a_n2292_n6800.n12 a_n2292_n6800.t17 0.0824
R949 a_n2292_n6800.n12 a_n2292_n6800.t18 0.0824
R950 a_n2292_n6800.n14 a_n2292_n6800.t15 0.0824
R951 a_n2292_n6800.n14 a_n2292_n6800.t16 0.0824
R952 a_n2292_n6800.n19 a_n2292_n6800.t1 0.0824
R953 a_n2292_n6800.n19 a_n2292_n6800.t2 0.0824
R954 a_n2292_n6800.n21 a_n2292_n6800.n18 0.0245
R955 a_n1292_n2000.n9 a_n1292_n2000.n4 10.495
R956 a_n1292_n2000.n9 a_n1292_n2000.n8 10.1847
R957 a_n1292_n2000.n10 a_n1292_n2000.n9 9.0005
R958 a_n1292_n2000.t4 a_n1292_n2000.n12 7.96427
R959 a_n1292_n2000.n6 a_n1292_n2000.t9 7.96427
R960 a_n1292_n2000.n3 a_n1292_n2000.t10 7.96426
R961 a_n1292_n2000.n4 a_n1292_n2000.n1 7.835
R962 a_n1292_n2000.n8 a_n1292_n2000.n7 7.835
R963 a_n1292_n2000.n10 a_n1292_n2000.n0 7.835
R964 a_n1292_n2000.n3 a_n1292_n2000.n2 7.69289
R965 a_n1292_n2000.n6 a_n1292_n2000.n5 7.69289
R966 a_n1292_n2000.n12 a_n1292_n2000.n11 7.69289
R967 a_n1292_n2000.n1 a_n1292_n2000.t13 0.0824
R968 a_n1292_n2000.n1 a_n1292_n2000.t14 0.0824
R969 a_n1292_n2000.n2 a_n1292_n2000.t11 0.0824
R970 a_n1292_n2000.n2 a_n1292_n2000.t12 0.0824
R971 a_n1292_n2000.n5 a_n1292_n2000.t7 0.0824
R972 a_n1292_n2000.n5 a_n1292_n2000.t8 0.0824
R973 a_n1292_n2000.n7 a_n1292_n2000.t5 0.0824
R974 a_n1292_n2000.n7 a_n1292_n2000.t6 0.0824
R975 a_n1292_n2000.n11 a_n1292_n2000.t2 0.0824
R976 a_n1292_n2000.n11 a_n1292_n2000.t3 0.0824
R977 a_n1292_n2000.n0 a_n1292_n2000.t0 0.0824
R978 a_n1292_n2000.n0 a_n1292_n2000.t1 0.0824
R979 a_n1292_n2000.n12 a_n1292_n2000.n10 0.0478684
R980 a_n1292_n2000.n4 a_n1292_n2000.n3 0.0478684
R981 a_n1292_n2000.n8 a_n1292_n2000.n6 0.0478684
R982 a_n3292_n2000.n9 a_n3292_n2000.n8 14.8163
R983 a_n3292_n2000.n9 a_n3292_n2000.n4 13.9016
R984 a_n3292_n2000.n10 a_n3292_n2000.n9 13.7637
R985 a_n3292_n2000.t4 a_n3292_n2000.n12 7.96427
R986 a_n3292_n2000.n6 a_n3292_n2000.t9 7.96427
R987 a_n3292_n2000.n3 a_n3292_n2000.t10 7.96426
R988 a_n3292_n2000.n4 a_n3292_n2000.n1 7.835
R989 a_n3292_n2000.n8 a_n3292_n2000.n7 7.835
R990 a_n3292_n2000.n10 a_n3292_n2000.n0 7.835
R991 a_n3292_n2000.n3 a_n3292_n2000.n2 7.69289
R992 a_n3292_n2000.n6 a_n3292_n2000.n5 7.69289
R993 a_n3292_n2000.n12 a_n3292_n2000.n11 7.69289
R994 a_n3292_n2000.n1 a_n3292_n2000.t13 0.0824
R995 a_n3292_n2000.n1 a_n3292_n2000.t14 0.0824
R996 a_n3292_n2000.n2 a_n3292_n2000.t11 0.0824
R997 a_n3292_n2000.n2 a_n3292_n2000.t12 0.0824
R998 a_n3292_n2000.n5 a_n3292_n2000.t7 0.0824
R999 a_n3292_n2000.n5 a_n3292_n2000.t8 0.0824
R1000 a_n3292_n2000.n7 a_n3292_n2000.t5 0.0824
R1001 a_n3292_n2000.n7 a_n3292_n2000.t6 0.0824
R1002 a_n3292_n2000.n11 a_n3292_n2000.t2 0.0824
R1003 a_n3292_n2000.n11 a_n3292_n2000.t3 0.0824
R1004 a_n3292_n2000.n0 a_n3292_n2000.t0 0.0824
R1005 a_n3292_n2000.n0 a_n3292_n2000.t1 0.0824
R1006 a_n3292_n2000.n12 a_n3292_n2000.n10 0.0478684
R1007 a_n3292_n2000.n4 a_n3292_n2000.n3 0.0478684
R1008 a_n3292_n2000.n8 a_n3292_n2000.n6 0.0478684
R1009 a_5164_6400.n2 a_5164_6400.t0 21.0371
R1010 a_5164_6400.n1 a_5164_6400.t1 7.94717
R1011 a_5164_6400.n3 a_5164_6400.n2 7.80881
R1012 a_5164_6400.n1 a_5164_6400.n0 7.6667
R1013 a_5164_6400.n0 a_5164_6400.t3 0.0915
R1014 a_5164_6400.n0 a_5164_6400.t2 0.0915
R1015 a_5164_6400.n3 a_5164_6400.t5 0.0915
R1016 a_5164_6400.t4 a_5164_6400.n3 0.0915
R1017 a_5164_6400.n2 a_5164_6400.n1 0.0478684
R1018 a_3884_6400.n2 a_3884_6400.t5 21.0371
R1019 a_3884_6400.n1 a_3884_6400.t0 7.94717
R1020 a_3884_6400.n3 a_3884_6400.n2 7.80881
R1021 a_3884_6400.n1 a_3884_6400.n0 7.6667
R1022 a_3884_6400.n0 a_3884_6400.t2 0.0915
R1023 a_3884_6400.n0 a_3884_6400.t1 0.0915
R1024 a_3884_6400.t4 a_3884_6400.n3 0.0915
R1025 a_3884_6400.n3 a_3884_6400.t3 0.0915
R1026 a_3884_6400.n2 a_3884_6400.n1 0.0478684
R1027 a_2604_6400.n2 a_2604_6400.t5 21.0371
R1028 a_2604_6400.n1 a_2604_6400.t0 7.94717
R1029 a_2604_6400.n3 a_2604_6400.n2 7.80881
R1030 a_2604_6400.n1 a_2604_6400.n0 7.6667
R1031 a_2604_6400.n0 a_2604_6400.t2 0.0915
R1032 a_2604_6400.n0 a_2604_6400.t1 0.0915
R1033 a_2604_6400.t4 a_2604_6400.n3 0.0915
R1034 a_2604_6400.n3 a_2604_6400.t3 0.0915
R1035 a_2604_6400.n2 a_2604_6400.n1 0.0478684
R1036 a_1324_6400.n2 a_1324_6400.t0 21.0371
R1037 a_1324_6400.n1 a_1324_6400.t1 7.94717
R1038 a_1324_6400.n3 a_1324_6400.n2 7.80881
R1039 a_1324_6400.n1 a_1324_6400.n0 7.6667
R1040 a_1324_6400.n0 a_1324_6400.t3 0.0915
R1041 a_1324_6400.n0 a_1324_6400.t2 0.0915
R1042 a_1324_6400.n3 a_1324_6400.t5 0.0915
R1043 a_1324_6400.t4 a_1324_6400.n3 0.0915
R1044 a_1324_6400.n2 a_1324_6400.n1 0.0478684
R1045 a_n2196_6400.n2 a_n2196_6400.t5 21.0371
R1046 a_n2196_6400.n1 a_n2196_6400.t0 7.94717
R1047 a_n2196_6400.n3 a_n2196_6400.n2 7.80881
R1048 a_n2196_6400.n1 a_n2196_6400.n0 7.6667
R1049 a_n2196_6400.n0 a_n2196_6400.t2 0.0915
R1050 a_n2196_6400.n0 a_n2196_6400.t1 0.0915
R1051 a_n2196_6400.t4 a_n2196_6400.n3 0.0915
R1052 a_n2196_6400.n3 a_n2196_6400.t3 0.0915
R1053 a_n2196_6400.n2 a_n2196_6400.n1 0.0478684
R1054 a_n3476_6400.n2 a_n3476_6400.t0 21.0371
R1055 a_n3476_6400.n1 a_n3476_6400.t1 7.94717
R1056 a_n3476_6400.n3 a_n3476_6400.n2 7.80881
R1057 a_n3476_6400.n1 a_n3476_6400.n0 7.6667
R1058 a_n3476_6400.n0 a_n3476_6400.t3 0.0915
R1059 a_n3476_6400.n0 a_n3476_6400.t2 0.0915
R1060 a_n3476_6400.n3 a_n3476_6400.t5 0.0915
R1061 a_n3476_6400.t4 a_n3476_6400.n3 0.0915
R1062 a_n3476_6400.n2 a_n3476_6400.n1 0.0478684
R1063 a_n4756_6400.n2 a_n4756_6400.t5 21.0371
R1064 a_n4756_6400.n1 a_n4756_6400.t0 7.94717
R1065 a_n4756_6400.n3 a_n4756_6400.n2 7.80881
R1066 a_n4756_6400.n1 a_n4756_6400.n0 7.6667
R1067 a_n4756_6400.n0 a_n4756_6400.t2 0.0915
R1068 a_n4756_6400.n0 a_n4756_6400.t1 0.0915
R1069 a_n4756_6400.t4 a_n4756_6400.n3 0.0915
R1070 a_n4756_6400.n3 a_n4756_6400.t3 0.0915
R1071 a_n4756_6400.n2 a_n4756_6400.n1 0.0478684
R1072 a_n6036_6400.n2 a_n6036_6400.t5 21.0371
R1073 a_n6036_6400.n1 a_n6036_6400.t0 7.94717
R1074 a_n6036_6400.n3 a_n6036_6400.n2 7.80881
R1075 a_n6036_6400.n1 a_n6036_6400.n0 7.6667
R1076 a_n6036_6400.n0 a_n6036_6400.t2 0.0915
R1077 a_n6036_6400.n0 a_n6036_6400.t1 0.0915
R1078 a_n6036_6400.t4 a_n6036_6400.n3 0.0915
R1079 a_n6036_6400.n3 a_n6036_6400.t3 0.0915
R1080 a_n6036_6400.n2 a_n6036_6400.n1 0.0478684
C0 OUTN OUTP 0.01866f
C1 LOAD_EN0_N LOAD_EN2_N 0.04666f
C2 EVEN_N OUTN 1.09302f
C3 LOAD_EN1_N VDD 5.67637f
C4 LOAD_EN1_N LOAD_EN3_N 0.04209f
C5 LOAD_EN0_N LOAD_EN1_N 0.95572f
C6 ODD_P OUTP 1.08183f
C7 LOAD_EN3_N VDD 5.57856f
C8 LOAD_EN0_N VDD 4.91361f
C9 EVEN_P OUTP 1.09319f
C10 LOAD_EN0_N LOAD_EN3_N 0.04122f
C11 LOAD_EN1_N LOAD_EN2_N 1.53541f
C12 OUTN VDD 0.21446f
C13 VDD OUTP 0.21446f
C14 ODD_N OUTN 1.08201f
C15 LOAD_EN2_N VDD 5.2554f
C16 LOAD_EN2_N LOAD_EN3_N 1.46836f
C17 VBIAS VSS 8.8549f
C18 CLK_N VSS 1.23919f
C19 CLK_P VSS 1.23916f
C20 EVEN_N VSS 1.29162f
C21 ODD_N VSS 1.28597f
C22 ODD_P VSS 1.28592f
C23 EVEN_P VSS 1.29162f
C24 OUTN VSS 7.30439f
C25 OUTP VSS 7.44475f
C26 LOAD_EN0_N VSS 1.65091f
C27 LOAD_EN1_N VSS 3.06804f
C28 LOAD_EN2_N VSS 4.77221f
C29 LOAD_EN3_N VSS 6.23421f
C30 VDD VSS 0.15612p
C31 a_n6036_6400.t3 VSS 0.60573f
C32 a_n6036_6400.t0 VSS 2.29274f
C33 a_n6036_6400.t2 VSS 0.60573f
C34 a_n6036_6400.t1 VSS 0.60573f
C35 a_n6036_6400.n0 VSS 1.53459f
C36 a_n6036_6400.n1 VSS 0.53371f
C37 a_n6036_6400.t5 VSS 1.20598f
C38 a_n6036_6400.n2 VSS 3.66568f
C39 a_n6036_6400.n3 VSS 1.53908f
C40 a_n6036_6400.t4 VSS 0.6069f
C41 a_n4756_6400.t3 VSS 0.6626f
C42 a_n4756_6400.t0 VSS 2.40354f
C43 a_n4756_6400.t2 VSS 0.6626f
C44 a_n4756_6400.t1 VSS 0.6626f
C45 a_n4756_6400.n0 VSS 1.58342f
C46 a_n4756_6400.n1 VSS 0.55069f
C47 a_n4756_6400.t5 VSS 1.24434f
C48 a_n4756_6400.n2 VSS 3.78231f
C49 a_n4756_6400.n3 VSS 1.58805f
C50 a_n4756_6400.t4 VSS 0.66406f
C51 a_n3476_6400.t5 VSS 0.68693f
C52 a_n3476_6400.t1 VSS 2.42813f
C53 a_n3476_6400.t3 VSS 0.68532f
C54 a_n3476_6400.t2 VSS 0.68532f
C55 a_n3476_6400.n0 VSS 1.58498f
C56 a_n3476_6400.n1 VSS 0.55124f
C57 a_n3476_6400.t0 VSS 1.24557f
C58 a_n3476_6400.n2 VSS 3.78604f
C59 a_n3476_6400.n3 VSS 1.58962f
C60 a_n3476_6400.t4 VSS 0.68532f
C61 a_n2196_6400.t3 VSS 0.64716f
C62 a_n2196_6400.t0 VSS 2.35223f
C63 a_n2196_6400.t2 VSS 0.64716f
C64 a_n2196_6400.t1 VSS 0.64716f
C65 a_n2196_6400.n0 VSS 1.55082f
C66 a_n2196_6400.n1 VSS 0.53935f
C67 a_n2196_6400.t5 VSS 1.21872f
C68 a_n2196_6400.n2 VSS 3.70443f
C69 a_n2196_6400.n3 VSS 1.55535f
C70 a_n2196_6400.t4 VSS 0.64857f
C71 a_1324_6400.t5 VSS 0.6355f
C72 a_1324_6400.t1 VSS 2.28754f
C73 a_1324_6400.t3 VSS 0.63409f
C74 a_1324_6400.t2 VSS 0.63409f
C75 a_1324_6400.n0 VSS 1.50383f
C76 a_1324_6400.n1 VSS 0.52301f
C77 a_1324_6400.t0 VSS 1.1818f
C78 a_1324_6400.n2 VSS 3.59219f
C79 a_1324_6400.n3 VSS 1.50823f
C80 a_1324_6400.t4 VSS 0.63409f
C81 a_2604_6400.t3 VSS 0.68534f
C82 a_2604_6400.t0 VSS 2.42819f
C83 a_2604_6400.t2 VSS 0.68534f
C84 a_2604_6400.t1 VSS 0.68534f
C85 a_2604_6400.n0 VSS 1.58503f
C86 a_2604_6400.n1 VSS 0.55125f
C87 a_2604_6400.t5 VSS 1.24561f
C88 a_2604_6400.n2 VSS 3.78616f
C89 a_2604_6400.n3 VSS 1.58967f
C90 a_2604_6400.t4 VSS 0.68694f
C91 a_3884_6400.t3 VSS 0.66262f
C92 a_3884_6400.t0 VSS 2.40362f
C93 a_3884_6400.t2 VSS 0.66262f
C94 a_3884_6400.t1 VSS 0.66262f
C95 a_3884_6400.n0 VSS 1.58348f
C96 a_3884_6400.n1 VSS 0.55071f
C97 a_3884_6400.t5 VSS 1.24439f
C98 a_3884_6400.n2 VSS 3.78245f
C99 a_3884_6400.n3 VSS 1.58811f
C100 a_3884_6400.t4 VSS 0.66408f
C101 a_5164_6400.t5 VSS 0.62031f
C102 a_5164_6400.t1 VSS 2.35909f
C103 a_5164_6400.t3 VSS 0.61914f
C104 a_5164_6400.t2 VSS 0.61914f
C105 a_5164_6400.n0 VSS 1.58278f
C106 a_5164_6400.n1 VSS 0.55047f
C107 a_5164_6400.t0 VSS 1.24385f
C108 a_5164_6400.n2 VSS 3.78079f
C109 a_5164_6400.n3 VSS 1.58741f
C110 a_5164_6400.t4 VSS 0.61914f
C111 a_n3292_n2000.t1 VSS 0.59902f
C112 a_n3292_n2000.t0 VSS 0.59902f
C113 a_n3292_n2000.n0 VSS 1.66501f
C114 a_n3292_n2000.t14 VSS 0.5987f
C115 a_n3292_n2000.t13 VSS 0.59781f
C116 a_n3292_n2000.n1 VSS 1.66501f
C117 a_n3292_n2000.t10 VSS 2.42402f
C118 a_n3292_n2000.t12 VSS 0.59781f
C119 a_n3292_n2000.t11 VSS 0.59781f
C120 a_n3292_n2000.n2 VSS 1.66012f
C121 a_n3292_n2000.n3 VSS 0.58104f
C122 a_n3292_n2000.n4 VSS 0.4951f
C123 a_n3292_n2000.t9 VSS 2.4262f
C124 a_n3292_n2000.t8 VSS 0.5991f
C125 a_n3292_n2000.t7 VSS 0.5991f
C126 a_n3292_n2000.n5 VSS 1.66012f
C127 a_n3292_n2000.n6 VSS 0.58104f
C128 a_n3292_n2000.t6 VSS 0.5991f
C129 a_n3292_n2000.t5 VSS 0.5991f
C130 a_n3292_n2000.n7 VSS 1.66501f
C131 a_n3292_n2000.n8 VSS 0.63959f
C132 a_n3292_n2000.n9 VSS 5.35712f
C133 a_n3292_n2000.n10 VSS 0.4852f
C134 a_n3292_n2000.t3 VSS 0.59902f
C135 a_n3292_n2000.t2 VSS 0.59902f
C136 a_n3292_n2000.n11 VSS 1.66012f
C137 a_n3292_n2000.n12 VSS 0.58104f
C138 a_n3292_n2000.t4 VSS 2.42612f
C139 a_n1292_n2000.t1 VSS 0.63924f
C140 a_n1292_n2000.t0 VSS 0.63924f
C141 a_n1292_n2000.n0 VSS 1.802f
C142 a_n1292_n2000.t14 VSS 0.63743f
C143 a_n1292_n2000.t13 VSS 0.63653f
C144 a_n1292_n2000.n1 VSS 1.802f
C145 a_n1292_n2000.t10 VSS 2.61299f
C146 a_n1292_n2000.t12 VSS 0.63653f
C147 a_n1292_n2000.t11 VSS 0.63653f
C148 a_n1292_n2000.n2 VSS 1.7967f
C149 a_n1292_n2000.n3 VSS 0.62885f
C150 a_n1292_n2000.n4 VSS 0.6098f
C151 a_n1292_n2000.t9 VSS 2.61574f
C152 a_n1292_n2000.t8 VSS 0.63839f
C153 a_n1292_n2000.t7 VSS 0.63839f
C154 a_n1292_n2000.n5 VSS 1.7967f
C155 a_n1292_n2000.n6 VSS 0.62885f
C156 a_n1292_n2000.t6 VSS 0.63839f
C157 a_n1292_n2000.t5 VSS 0.63839f
C158 a_n1292_n2000.n7 VSS 1.802f
C159 a_n1292_n2000.n8 VSS 0.55734f
C160 a_n1292_n2000.n9 VSS 3.39563f
C161 a_n1292_n2000.n10 VSS 0.45932f
C162 a_n1292_n2000.t3 VSS 0.63924f
C163 a_n1292_n2000.t2 VSS 0.63924f
C164 a_n1292_n2000.n11 VSS 1.7967f
C165 a_n1292_n2000.n12 VSS 0.62885f
C166 a_n1292_n2000.t4 VSS 2.61661f
C167 a_n2292_n6800.n0 VSS 0.58323f
C168 a_n2292_n6800.t10 VSS 0.35135f
C169 a_n2292_n6800.t9 VSS 0.35135f
C170 a_n2292_n6800.n1 VSS 0.82944f
C171 a_n2292_n6800.t6 VSS 0.35135f
C172 a_n2292_n6800.t5 VSS 0.35135f
C173 a_n2292_n6800.n2 VSS 0.82944f
C174 a_n2292_n6800.t4 VSS 0.35135f
C175 a_n2292_n6800.t3 VSS 0.35135f
C176 a_n2292_n6800.n3 VSS 0.82944f
C177 a_n2292_n6800.n4 VSS 0.20638f
C178 a_n2292_n6800.t23 VSS 0.36633f
C179 a_n2292_n6800.t22 VSS 0.36633f
C180 a_n2292_n6800.n5 VSS 0.83643f
C181 a_n2292_n6800.n6 VSS 0.17474f
C182 a_n2292_n6800.t19 VSS 1.28089f
C183 a_n2292_n6800.t21 VSS 0.36633f
C184 a_n2292_n6800.t20 VSS 0.36633f
C185 a_n2292_n6800.n7 VSS 0.83451f
C186 a_n2292_n6800.n8 VSS 0.18019f
C187 a_n2292_n6800.n9 VSS 0.16156f
C188 a_n2292_n6800.n10 VSS 0.83392f
C189 a_n2292_n6800.t14 VSS 1.28353f
C190 a_n2292_n6800.n11 VSS 0.17796f
C191 a_n2292_n6800.t18 VSS 0.36699f
C192 a_n2292_n6800.t17 VSS 0.36699f
C193 a_n2292_n6800.n12 VSS 0.83451f
C194 a_n2292_n6800.n13 VSS 0.18019f
C195 a_n2292_n6800.t16 VSS 0.36699f
C196 a_n2292_n6800.t15 VSS 0.36699f
C197 a_n2292_n6800.n14 VSS 0.83451f
C198 a_n2292_n6800.n15 VSS 0.15181f
C199 a_n2292_n6800.n16 VSS 0.7977f
C200 a_n2292_n6800.n17 VSS 1.39392f
C201 a_n2292_n6800.n18 VSS 0.71545f
C202 a_n2292_n6800.t0 VSS 1.26764f
C203 a_n2292_n6800.t2 VSS 0.35135f
C204 a_n2292_n6800.t1 VSS 0.35135f
C205 a_n2292_n6800.n19 VSS 0.82944f
C206 a_n2292_n6800.n20 VSS 0.40414f
C207 a_n2292_n6800.n21 VSS 0.67818f
C208 a_n2292_n6800.n22 VSS 0.20638f
C209 a_n2292_n6800.t8 VSS 0.35135f
C210 a_n2292_n6800.t7 VSS 0.35135f
C211 a_n2292_n6800.n23 VSS 0.82944f
C212 a_n2292_n6800.n24 VSS 0.20638f
C213 a_n2292_n6800.n25 VSS 0.20638f
C214 a_n2292_n6800.t12 VSS 0.35135f
C215 a_n2292_n6800.t11 VSS 0.35135f
C216 a_n2292_n6800.n26 VSS 0.82944f
C217 a_n2292_n6800.n27 VSS 0.20638f
C218 a_n2292_n6800.n28 VSS 0.18912f
C219 a_n2292_n6800.t13 VSS 1.26243f
C220 VSS.t23 VSS 0.12021f
C221 VSS.t19 VSS 0.12263f
C222 VSS.t43 VSS 0.12263f
C223 VSS.t41 VSS 0.12021f
C224 VSS.t39 VSS 0.12021f
C225 VSS.t37 VSS 0.12021f
C226 VSS.t35 VSS 0.12021f
C227 VSS.t33 VSS 0.12021f
C228 VSS.t31 VSS 0.12021f
C229 VSS.t29 VSS 0.12021f
C230 VSS.t27 VSS 0.12021f
C231 VSS.t25 VSS 0.12021f
C232 VSS.t21 VSS 0.12021f
C233 VSS.t17 VSS 0.12021f
C234 VDD.n0 VSS 0.34152f
C235 VDD.n1 VSS 0.21598f
C236 VDD.t71 VSS 0.36189f
C237 VDD.t67 VSS 0.36189f
C238 VDD.n2 VSS 0.52557f
C239 VDD.n3 VSS 0.09927f
C240 VDD.t72 VSS 2.25412f
C241 VDD.t79 VSS 0.36189f
C242 VDD.t77 VSS 0.36189f
C243 VDD.n4 VSS 0.52557f
C244 VDD.n5 VSS 0.09927f
C245 VDD.n6 VSS 0.21598f
C246 VDD.n7 VSS 0.0243f
C247 VDD.t10 VSS 1.58609f
C248 VDD.n8 VSS 0.0243f
C249 VDD.n9 VSS 0.20315f
C250 VDD.n10 VSS 0.0243f
C251 VDD.t61 VSS 0.22264f
C252 VDD.n11 VSS 2.79213f
C253 VDD.t35 VSS 0.32498f
C254 VDD.t37 VSS 0.32498f
C255 VDD.n12 VSS 0.52557f
C256 VDD.n13 VSS 0.09927f
C257 VDD.t39 VSS 0.90114f
C258 VDD.n14 VSS 0.15064f
C259 VDD.n15 VSS 2.01386f
C260 VDD.t38 VSS 2.08608f
C261 VDD.t34 VSS 1.05739f
C262 VDD.t36 VSS 1.05739f
C263 VDD.t32 VSS 1.05739f
C264 VDD.t30 VSS 1.58609f
C265 VDD.t12 VSS 1.05739f
C266 VDD.t14 VSS 1.05739f
C267 VDD.t16 VSS 1.05739f
C268 VDD.t18 VSS 1.58609f
C269 VDD.n16 VSS 2.14339f
C270 VDD.t17 VSS 0.36827f
C271 VDD.t15 VSS 0.36827f
C272 VDD.n17 VSS 0.52557f
C273 VDD.n18 VSS 0.09927f
C274 VDD.t19 VSS 0.94471f
C275 VDD.n19 VSS 0.14389f
C276 VDD.n20 VSS 0.18211f
C277 VDD.t33 VSS 0.32498f
C278 VDD.t31 VSS 0.32615f
C279 VDD.n21 VSS 0.52557f
C280 VDD.n22 VSS 0.13977f
C281 VDD.n23 VSS 0.05129f
C282 VDD.n24 VSS 0.21598f
C283 VDD.n25 VSS 0.21598f
C284 VDD.n26 VSS 0.21598f
C285 VDD.n27 VSS 0.05129f
C286 VDD.t13 VSS 0.36827f
C287 VDD.t11 VSS 0.36972f
C288 VDD.n28 VSS 0.52557f
C289 VDD.n29 VSS 0.13977f
C290 VDD.t54 VSS 0.39055f
C291 VDD.t58 VSS 0.39055f
C292 VDD.n30 VSS 0.52557f
C293 VDD.n31 VSS 0.09927f
C294 VDD.t60 VSS 0.96714f
C295 VDD.n32 VSS 0.14389f
C296 VDD.n33 VSS 0.18211f
C297 VDD.n34 VSS 2.14339f
C298 VDD.t59 VSS 1.58609f
C299 VDD.t53 VSS 1.05739f
C300 VDD.t57 VSS 1.05739f
C301 VDD.t55 VSS 1.05739f
C302 VDD.t43 VSS 1.58609f
C303 VDD.t74 VSS 1.05739f
C304 VDD.t76 VSS 1.05739f
C305 VDD.t78 VSS 1.05739f
C306 VDD.t80 VSS 1.58609f
C307 VDD.n35 VSS 2.14339f
C308 VDD.t81 VSS 0.9383f
C309 VDD.n36 VSS 0.14389f
C310 VDD.n37 VSS 0.18211f
C311 VDD.t56 VSS 0.39055f
C312 VDD.t44 VSS 0.39215f
C313 VDD.n38 VSS 0.52557f
C314 VDD.n39 VSS 0.13977f
C315 VDD.n40 VSS 0.05129f
C316 VDD.n41 VSS 0.21598f
C317 VDD.n42 VSS 0.21598f
C318 VDD.n43 VSS 0.0243f
C319 VDD.n44 VSS 0.05129f
C320 VDD.t75 VSS 0.36189f
C321 VDD.t73 VSS 0.36331f
C322 VDD.n45 VSS 0.52557f
C323 VDD.n46 VSS 0.15327f
C324 VDD.n47 VSS 2.51014f
C325 VDD.t69 VSS 0.9383f
C326 VDD.n48 VSS 0.15739f
C327 VDD.n49 VSS 2.48315f
C328 VDD.t68 VSS 2.25412f
C329 VDD.t70 VSS 1.05739f
C330 VDD.t66 VSS 1.05739f
C331 VDD.t64 VSS 1.05739f
C332 VDD.t62 VSS 1.58609f
C333 VDD.n50 VSS 2.14339f
C334 VDD.n51 VSS 0.05129f
C335 VDD.n52 VSS 0.21598f
C336 VDD.t7 VSS 0.36827f
C337 VDD.t5 VSS 0.36827f
C338 VDD.n53 VSS 0.52557f
C339 VDD.n54 VSS 0.09927f
C340 VDD.t51 VSS 1.58609f
C341 VDD.t49 VSS 1.05739f
C342 VDD.t47 VSS 1.05739f
C343 VDD.t41 VSS 1.05739f
C344 VDD.t45 VSS 1.58609f
C345 VDD.t42 VSS 0.39055f
C346 VDD.t46 VSS 0.39215f
C347 VDD.n55 VSS 0.52557f
C348 VDD.n56 VSS 0.13977f
C349 VDD.t9 VSS 0.94471f
C350 VDD.n57 VSS 0.14389f
C351 VDD.n58 VSS 0.18211f
C352 VDD.n59 VSS 2.14339f
C353 VDD.t8 VSS 1.58609f
C354 VDD.t6 VSS 1.05739f
C355 VDD.t4 VSS 1.05739f
C356 VDD.t2 VSS 1.05739f
C357 VDD.t0 VSS 1.58609f
C358 VDD.n60 VSS 2.14339f
C359 VDD.n61 VSS 0.05129f
C360 VDD.t40 VSS 0.22264f
C361 VDD.t28 VSS 1.58609f
C362 VDD.t26 VSS 1.05739f
C363 VDD.t24 VSS 1.05739f
C364 VDD.t22 VSS 1.05739f
C365 VDD.t20 VSS 2.08608f
C366 VDD.t23 VSS 0.32498f
C367 VDD.t21 VSS 0.32615f
C368 VDD.n62 VSS 0.52557f
C369 VDD.n63 VSS 0.14652f
C370 VDD.n64 VSS 2.04085f
C371 VDD.n65 VSS 2.79213f
C372 VDD.n66 VSS 0.20315f
C373 VDD.n67 VSS 0.21598f
C374 VDD.n68 VSS 0.0243f
C375 VDD.t27 VSS 0.32498f
C376 VDD.t25 VSS 0.32498f
C377 VDD.n69 VSS 0.52557f
C378 VDD.n70 VSS 0.09927f
C379 VDD.t29 VSS 0.90114f
C380 VDD.n71 VSS 0.14389f
C381 VDD.n72 VSS 0.18211f
C382 VDD.t3 VSS 0.36827f
C383 VDD.t1 VSS 0.36972f
C384 VDD.n73 VSS 0.52557f
C385 VDD.n74 VSS 0.13977f
C386 VDD.n75 VSS 0.05129f
C387 VDD.n76 VSS 0.0243f
C388 VDD.n77 VSS 0.21598f
C389 VDD.n78 VSS 0.21598f
C390 VDD.n79 VSS 0.21598f
C391 VDD.n80 VSS 0.0243f
C392 VDD.t50 VSS 0.39055f
C393 VDD.t48 VSS 0.39055f
C394 VDD.n81 VSS 0.52557f
C395 VDD.n82 VSS 0.09927f
C396 VDD.t52 VSS 0.96714f
C397 VDD.n83 VSS 0.14389f
C398 VDD.n84 VSS 0.18211f
C399 VDD.t65 VSS 0.36189f
C400 VDD.t63 VSS 0.36331f
C401 VDD.n85 VSS 0.52557f
C402 VDD.n86 VSS 0.13977f
C403 VDD.n87 VSS 0.05129f
C404 VDD.n88 VSS 0.0243f
C405 VDD.n89 VSS 0.27402f
C406 LOAD_EN3_N.n0 VSS 0.1071f
C407 LOAD_EN3_N.n1 VSS 0.14065f
C408 LOAD_EN3_N.n2 VSS 0.14598f
C409 LOAD_EN3_N.n3 VSS 0.14065f
C410 LOAD_EN3_N.n4 VSS 0.14598f
C411 LOAD_EN3_N.n5 VSS 0.14598f
C412 LOAD_EN3_N.n6 VSS 0.02523f
C413 LOAD_EN3_N.n7 VSS 0.1071f
C414 LOAD_EN3_N.n8 VSS 0.62237f
C415 LOAD_EN3_N.n9 VSS 0.1071f
C416 LOAD_EN3_N.n10 VSS 0.14065f
C417 LOAD_EN3_N.n11 VSS 0.14065f
C418 LOAD_EN3_N.n12 VSS 0.14598f
C419 LOAD_EN3_N.n13 VSS 0.14598f
C420 LOAD_EN3_N.n14 VSS 0.14598f
C421 LOAD_EN3_N.n15 VSS 0.02523f
C422 LOAD_EN3_N.n16 VSS 0.1071f
C423 LOAD_EN3_N.n17 VSS 0.1586f
C424 LOAD_EN2_N.n0 VSS 0.13303f
C425 LOAD_EN2_N.n1 VSS 0.03134f
C426 LOAD_EN2_N.n2 VSS 0.17472f
C427 LOAD_EN2_N.n3 VSS 0.18133f
C428 LOAD_EN2_N.n4 VSS 0.18133f
C429 LOAD_EN2_N.n5 VSS 0.18133f
C430 LOAD_EN2_N.n6 VSS 0.17472f
C431 LOAD_EN2_N.n7 VSS 0.13303f
C432 LOAD_EN2_N.n8 VSS 0.27333f
C433 LOAD_EN2_N.n9 VSS 0.13303f
C434 LOAD_EN2_N.n10 VSS 0.17472f
C435 LOAD_EN2_N.n11 VSS 0.17472f
C436 LOAD_EN2_N.n12 VSS 0.18133f
C437 LOAD_EN2_N.n13 VSS 0.18133f
C438 LOAD_EN2_N.n14 VSS 0.18133f
C439 LOAD_EN2_N.n15 VSS 0.03134f
C440 LOAD_EN2_N.n16 VSS 0.13303f
C441 LOAD_EN2_N.n17 VSS 0.71601f
C442 LOAD_EN1_N.n0 VSS 0.14638f
C443 LOAD_EN1_N.n1 VSS 0.19225f
C444 LOAD_EN1_N.n2 VSS 0.19953f
C445 LOAD_EN1_N.n3 VSS 0.19225f
C446 LOAD_EN1_N.n4 VSS 0.19953f
C447 LOAD_EN1_N.n5 VSS 0.19953f
C448 LOAD_EN1_N.n6 VSS 0.03449f
C449 LOAD_EN1_N.n7 VSS 0.14639f
C450 LOAD_EN1_N.n8 VSS 0.74603f
C451 LOAD_EN1_N.n9 VSS 0.14639f
C452 LOAD_EN1_N.n10 VSS 0.19225f
C453 LOAD_EN1_N.n11 VSS 0.19225f
C454 LOAD_EN1_N.n12 VSS 0.19953f
C455 LOAD_EN1_N.n13 VSS 0.19953f
C456 LOAD_EN1_N.n14 VSS 0.19953f
C457 LOAD_EN1_N.n15 VSS 0.03449f
C458 LOAD_EN1_N.n16 VSS 0.14638f
C459 LOAD_EN1_N.n17 VSS 0.15227f
C460 LOAD_EN0_N.n0 VSS 0.12955f
C461 LOAD_EN0_N.n1 VSS 0.03044f
C462 LOAD_EN0_N.n2 VSS 0.1697f
C463 LOAD_EN0_N.n3 VSS 0.17613f
C464 LOAD_EN0_N.n4 VSS 0.17613f
C465 LOAD_EN0_N.n5 VSS 0.17613f
C466 LOAD_EN0_N.n6 VSS 0.1697f
C467 LOAD_EN0_N.n7 VSS 0.12886f
C468 LOAD_EN0_N.n8 VSS 0.38697f
C469 LOAD_EN0_N.n9 VSS 0.12955f
C470 LOAD_EN0_N.n10 VSS 0.1697f
C471 LOAD_EN0_N.n11 VSS 0.1697f
C472 LOAD_EN0_N.n12 VSS 0.17613f
C473 LOAD_EN0_N.n13 VSS 0.17613f
C474 LOAD_EN0_N.n14 VSS 0.17613f
C475 LOAD_EN0_N.n15 VSS 0.03044f
C476 LOAD_EN0_N.n16 VSS 0.12886f
C477 LOAD_EN0_N.n17 VSS 0.35528f
C478 OUTP.t1 VSS 0.14433f
C479 OUTP.t8 VSS 0.12221f
C480 OUTP.n0 VSS 1.84928f
C481 OUTP.t2 VSS 0.12221f
C482 OUTP.n1 VSS 1.139f
C483 OUTP.t0 VSS 0.12221f
C484 OUTP.n2 VSS 1.06581f
C485 OUTP.t9 VSS 0.12221f
C486 OUTP.n3 VSS 1.22845f
C487 OUTP.t14 VSS 1.87705f
C488 OUTP.n4 VSS 0.2655f
C489 OUTP.t11 VSS 0.48967f
C490 OUTP.t10 VSS 0.48878f
C491 OUTP.n5 VSS 1.26452f
C492 OUTP.t12 VSS 0.48878f
C493 OUTP.t13 VSS 0.48878f
C494 OUTP.n6 VSS 1.26452f
C495 OUTP.n7 VSS 0.26931f
C496 OUTP.n8 VSS 0.22605f
C497 OUTP.n9 VSS 0.73807f
C498 OUTP.t4 VSS 0.49099f
C499 OUTP.t3 VSS 0.49009f
C500 OUTP.n10 VSS 1.26738f
C501 OUTP.n11 VSS 0.26057f
C502 OUTP.t6 VSS 0.49009f
C503 OUTP.t5 VSS 0.49009f
C504 OUTP.n12 VSS 1.26452f
C505 OUTP.n13 VSS 0.26931f
C506 OUTP.t7 VSS 1.87539f
C507 OUTP.n14 VSS 0.2408f
C508 OUTP.n15 VSS 0.64705f
C509 OUTP.n16 VSS 0.55567f
C510 OUTN.t9 VSS 0.14562f
C511 OUTN.t0 VSS 0.1233f
C512 OUTN.n0 VSS 1.86577f
C513 OUTN.t6 VSS 0.1233f
C514 OUTN.n1 VSS 1.14915f
C515 OUTN.t8 VSS 0.1233f
C516 OUTN.n2 VSS 1.07532f
C517 OUTN.t7 VSS 0.1233f
C518 OUTN.n3 VSS 1.2394f
C519 OUTN.t4 VSS 1.89473f
C520 OUTN.n4 VSS 0.26787f
C521 OUTN.t5 VSS 0.495f
C522 OUTN.t3 VSS 0.49409f
C523 OUTN.n5 VSS 1.2758f
C524 OUTN.t2 VSS 0.49409f
C525 OUTN.t1 VSS 0.49409f
C526 OUTN.n6 VSS 1.2758f
C527 OUTN.n7 VSS 0.27171f
C528 OUTN.n8 VSS 0.22807f
C529 OUTN.n9 VSS 0.60792f
C530 OUTN.t14 VSS 0.4929f
C531 OUTN.t13 VSS 0.492f
C532 OUTN.n10 VSS 1.27868f
C533 OUTN.n11 VSS 0.2629f
C534 OUTN.t11 VSS 0.492f
C535 OUTN.t10 VSS 0.492f
C536 OUTN.n12 VSS 1.2758f
C537 OUTN.n13 VSS 0.27171f
C538 OUTN.t12 VSS 1.88966f
C539 OUTN.n14 VSS 0.24295f
C540 OUTN.n15 VSS 0.78956f
C541 OUTN.n16 VSS 0.56062f
C542 EVEN_P.n0 VSS 0.03758f
C543 EVEN_P.n1 VSS 0.10938f
C544 EVEN_P.n2 VSS 0.10788f
C545 EVEN_P.n3 VSS 0.1114f
C546 EVEN_P.n4 VSS 0.1114f
C547 EVEN_P.n5 VSS 0.1114f
C548 EVEN_P.n6 VSS 0.10822f
C549 EVEN_P.n7 VSS 0.02899f
C550 ODD_P.n0 VSS 0.03794f
C551 ODD_P.n1 VSS 0.11042f
C552 ODD_P.n2 VSS 0.10892f
C553 ODD_P.n3 VSS 0.11247f
C554 ODD_P.n4 VSS 0.11247f
C555 ODD_P.n5 VSS 0.11247f
C556 ODD_P.n6 VSS 0.10926f
C557 ODD_P.n7 VSS 0.02927f
C558 ODD_N.n0 VSS 0.03817f
C559 ODD_N.n1 VSS 0.11111f
C560 ODD_N.n2 VSS 0.10959f
C561 ODD_N.n3 VSS 0.11317f
C562 ODD_N.n4 VSS 0.11317f
C563 ODD_N.n5 VSS 0.11317f
C564 ODD_N.n6 VSS 0.10994f
C565 ODD_N.n7 VSS 0.02945f
C566 EVEN_N.n0 VSS 0.0376f
C567 EVEN_N.n1 VSS 0.10944f
C568 EVEN_N.n2 VSS 0.10795f
C569 EVEN_N.n3 VSS 0.11147f
C570 EVEN_N.n4 VSS 0.11147f
C571 EVEN_N.n5 VSS 0.11147f
C572 EVEN_N.n6 VSS 0.10829f
C573 EVEN_N.n7 VSS 0.02901f
C574 CLK_P.n0 VSS 0.03725f
C575 CLK_P.n1 VSS 0.10841f
C576 CLK_P.n2 VSS 0.10693f
C577 CLK_P.n3 VSS 0.11042f
C578 CLK_P.n4 VSS 0.11042f
C579 CLK_P.n5 VSS 0.11042f
C580 CLK_P.n6 VSS 0.10726f
C581 CLK_P.n7 VSS 0.02873f
C582 CLK_N.n0 VSS 0.03743f
C583 CLK_N.n1 VSS 0.10894f
C584 CLK_N.n2 VSS 0.10745f
C585 CLK_N.n3 VSS 0.11096f
C586 CLK_N.n4 VSS 0.11096f
C587 CLK_N.n5 VSS 0.11096f
C588 CLK_N.n6 VSS 0.10779f
C589 CLK_N.n7 VSS 0.02887f
C590 VBIAS.n0 VSS 0.02197f
C591 VBIAS.n1 VSS 0.02301f
C592 VBIAS.n2 VSS 0.09112f
C593 VBIAS.n3 VSS 0.08547f
C594 VBIAS.n4 VSS 0.09112f
C595 VBIAS.n5 VSS 0.09112f
C596 VBIAS.n6 VSS 0.0647f
C597 VBIAS.n7 VSS 0.02301f
C598 VBIAS.n8 VSS 0.02301f
C599 VBIAS.n9 VSS 0.09112f
C600 VBIAS.n10 VSS 0.09112f
C601 VBIAS.n11 VSS 0.02301f
C602 VBIAS.n12 VSS 0.02301f
C603 VBIAS.n13 VSS 0.02301f
C604 VBIAS.n14 VSS 0.0647f
C605 VBIAS.n15 VSS 0.08547f
C606 VBIAS.n16 VSS 0.09112f
C607 VBIAS.n17 VSS 0.09112f
C608 VBIAS.n18 VSS 0.09112f
C609 VBIAS.n19 VSS 0.09112f
C610 VBIAS.n20 VSS 0.09112f
C611 VBIAS.n21 VSS 0.09112f
C612 VBIAS.n22 VSS 0.09112f
C613 VBIAS.n23 VSS 0.01443f
.ends
