* PEX produced using /foss/tools/sak/sak-pex.sh with m=3 and s=1 (extresist threshold=0 mOhm, minres=1 mOhm, mindelay=0 ps)
* NGSPICE file created from serializer_tx_pex.ext - technology: gf180mcuD

.subckt serializer_tx_pex EVEN_P EVEN_N ODD_P ODD_N CLK_P CLK_N VBIAS LOAD_EN0_N LOAD_EN1_N
+ LOAD_EN2_N LOAD_EN3_N VDD VSS OUTP OUTN
X0 a_n2292_n6800.t11 VBIAS.t2 VSS.t54 VSS.t53 nfet_03v3 ad=5.2p pd=20.52u as=5.2p ps=20.52u w=20u l=0.28u
X1 a_n4756_6400.t4 LOAD_EN2_N.t6 VDD.t151 VDD.t150 pfet_03v3 ad=5.2p pd=20.52u as=5.2p ps=20.52u w=20u l=0.28u
X2 a_n4756_6400.t0 OUTP.t7 VSS.t15 ppolyf_u r_width=1u r_length=0.8u
X3 a_n6036_6400.t5 OUTP.t8 VSS.t16 ppolyf_u r_width=1u r_length=0.8u
X4 VDD.t153 LOAD_EN2_N.t5 a_n4756_6400.t5 VDD.t152 pfet_03v3 ad=8.8p pd=40.88u as=5.2p ps=20.52u w=20u l=0.28u
X5 a_n2292_n6800.t3 VBIAS.t10 VSS.t38 VSS.t37 nfet_03v3 ad=5.2p pd=20.52u as=5.2p ps=20.52u w=20u l=0.28u
X6 a_n2292_n6800.t19 CLK_P.t4 a_n3292_n2000.t10 VSS.t71 nfet_03v3 ad=5.2p pd=20.52u as=8.8p ps=40.88u w=20u l=0.28u
X7 VDD.t97 LOAD_EN3_N.t2 a_10284_6400.t2 VDD.t96 pfet_03v3 ad=5.2p pd=20.52u as=5.2p ps=20.52u w=20u l=0.28u
X8 VDD.t9 LOAD_EN3_N.t39 a_n8596_6400.t0 VDD.t8 pfet_03v3 ad=5.2p pd=20.52u as=8.8p ps=40.88u w=20u l=0.28u
X9 a_10284_6400.t1 LOAD_EN3_N.t3 VDD.t95 VDD.t94 pfet_03v3 ad=5.2p pd=20.52u as=5.2p ps=20.52u w=20u l=0.28u
X10 VDD.t11 LOAD_EN3_N.t44 a_n9876_6400.t0 VDD.t10 pfet_03v3 ad=5.2p pd=20.52u as=8.8p ps=40.88u w=20u l=0.28u
X11 VDD.t73 LOAD_EN3_N.t10 a_7724_6400.t4 VDD.t72 pfet_03v3 ad=8.8p pd=40.88u as=5.2p ps=20.52u w=20u l=0.28u
X12 a_n2196_6400.t5 OUTP.t12 VSS.t23 ppolyf_u r_width=1u r_length=0.8u
X13 a_n3292_n2000.t13 CLK_P.t1 a_n2292_n6800.t23 VSS.t74 nfet_03v3 ad=5.2p pd=20.52u as=5.2p ps=20.52u w=20u l=0.28u
X14 a_n9876_6400.t1 LOAD_EN3_N.t43 VDD.t7 VDD.t6 pfet_03v3 ad=5.2p pd=20.52u as=5.2p ps=20.52u w=20u l=0.28u
X15 a_n2292_n6800.t15 CLK_N.t2 a_n1292_n2000.t12 VSS.t68 nfet_03v3 ad=5.2p pd=20.52u as=5.2p ps=20.52u w=20u l=0.28u
X16 VDD.t110 LOAD_EN0_N.t5 a_n2196_6400.t4 VDD.t109 pfet_03v3 ad=8.8p pd=40.88u as=5.2p ps=20.52u w=20u l=0.28u
X17 VDD.t13 LOAD_EN3_N.t29 a_n6036_6400.t0 VDD.t12 pfet_03v3 ad=5.2p pd=20.52u as=8.8p ps=40.88u w=20u l=0.28u
X18 a_n1292_n2000.t9 ODD_P.t0 OUTP.t4 VSS.t10 nfet_03v3 ad=8.8p pd=40.88u as=5.2p ps=20.52u w=20u l=0.28u
X19 a_9004_6400.t3 LOAD_EN3_N.t6 VDD.t83 VDD.t82 pfet_03v3 ad=5.2p pd=20.52u as=5.2p ps=20.52u w=20u l=0.28u
X20 VDD.t17 LOAD_EN3_N.t47 a_n11156_6400.t2 VDD.t16 pfet_03v3 ad=5.2p pd=20.52u as=5.2p ps=20.52u w=20u l=0.28u
X21 VDD.t161 LOAD_EN2_N.t0 a_3884_6400.t5 VDD.t160 pfet_03v3 ad=8.8p pd=40.88u as=5.2p ps=20.52u w=20u l=0.28u
X22 VDD.t15 LOAD_EN3_N.t49 a_n11156_6400.t0 VDD.t14 pfet_03v3 ad=5.2p pd=20.52u as=8.8p ps=40.88u w=20u l=0.28u
X23 VDD.t59 LOAD_EN3_N.t20 a_5164_6400.t4 VDD.t58 pfet_03v3 ad=8.8p pd=40.88u as=5.2p ps=20.52u w=20u l=0.28u
X24 a_9004_6400.t5 OUTN.t5 VSS.t5 ppolyf_u r_width=1u r_length=0.8u
X25 VDD.t87 LOAD_EN3_N.t7 a_9004_6400.t2 VDD.t86 pfet_03v3 ad=5.2p pd=20.52u as=5.2p ps=20.52u w=20u l=0.28u
X26 OUTN.t15 EVEN_N.t3 a_n3292_n2000.t6 VSS.t62 nfet_03v3 ad=5.2p pd=20.52u as=5.2p ps=20.52u w=20u l=0.28u
X27 a_n3292_n2000.t4 EVEN_P.t0 OUTP.t13 VSS.t30 nfet_03v3 ad=8.8p pd=40.88u as=5.2p ps=20.52u w=20u l=0.28u
X28 a_n2292_n6800.t9 VBIAS.t4 VSS.t44 VSS.t43 nfet_03v3 ad=5.2p pd=20.52u as=5.2p ps=20.52u w=20u l=0.28u
X29 a_n3476_6400.t0 OUTP.t10 VSS.t20 ppolyf_u r_width=1u r_length=0.8u
X30 a_5164_6400.t3 LOAD_EN3_N.t21 VDD.t57 VDD.t56 pfet_03v3 ad=5.2p pd=20.52u as=5.2p ps=20.52u w=20u l=0.28u
X31 a_n2292_n6800.t17 CLK_N.t0 a_n1292_n2000.t14 VSS.t70 nfet_03v3 ad=8.8p pd=40.88u as=5.2p ps=20.52u w=20u l=0.28u
X32 a_n3292_n2000.t11 CLK_P.t3 a_n2292_n6800.t20 VSS.t72 nfet_03v3 ad=5.2p pd=20.52u as=5.2p ps=20.52u w=20u l=0.28u
X33 VDD.t39 LOAD_EN3_N.t32 a_n7316_6400.t2 VDD.t38 pfet_03v3 ad=5.2p pd=20.52u as=5.2p ps=20.52u w=20u l=0.28u
X34 VDD.t37 LOAD_EN3_N.t34 a_n7316_6400.t0 VDD.t36 pfet_03v3 ad=5.2p pd=20.52u as=8.8p ps=40.88u w=20u l=0.28u
X35 a_5164_6400.t5 OUTN.t8 VSS.t17 ppolyf_u r_width=1u r_length=0.8u
X36 a_n2292_n6800.t5 VBIAS.t8 VSS.t42 VSS.t41 nfet_03v3 ad=5.2p pd=20.52u as=5.2p ps=20.52u w=20u l=0.28u
X37 VSS.t56 VBIAS.t1 a_n2292_n6800.t12 VSS.t55 nfet_03v3 ad=5.2p pd=20.52u as=5.2p ps=20.52u w=20u l=0.28u
X38 VDD.t67 LOAD_EN3_N.t17 a_6444_6400.t2 VDD.t66 pfet_03v3 ad=5.2p pd=20.52u as=5.2p ps=20.52u w=20u l=0.28u
X39 a_6444_6400.t5 OUTN.t7 VSS.t13 ppolyf_u r_width=1u r_length=0.8u
X40 VDD.t69 LOAD_EN3_N.t15 a_6444_6400.t4 VDD.t68 pfet_03v3 ad=8.8p pd=40.88u as=5.2p ps=20.52u w=20u l=0.28u
X41 OUTN.t3 ODD_N.t3 a_n1292_n2000.t1 VSS.t1 nfet_03v3 ad=5.2p pd=20.52u as=5.2p ps=20.52u w=20u l=0.28u
X42 a_n3292_n2000.t2 EVEN_P.t2 OUTP.t14 VSS.t28 nfet_03v3 ad=5.2p pd=20.52u as=5.2p ps=20.52u w=20u l=0.28u
X43 a_n8596_6400.t1 LOAD_EN3_N.t38 VDD.t29 VDD.t28 pfet_03v3 ad=5.2p pd=20.52u as=5.2p ps=20.52u w=20u l=0.28u
X44 OUTN.t17 EVEN_N.t1 a_n3292_n2000.t8 VSS.t64 nfet_03v3 ad=5.2p pd=20.52u as=5.2p ps=20.52u w=20u l=0.28u
X45 VSS.t34 VBIAS.t11 a_n2292_n6800.t2 VSS.t33 nfet_03v3 ad=5.2p pd=20.52u as=5.2p ps=20.52u w=20u l=0.28u
X46 a_6444_6400.t3 LOAD_EN3_N.t16 VDD.t63 VDD.t62 pfet_03v3 ad=5.2p pd=20.52u as=5.2p ps=20.52u w=20u l=0.28u
X47 VDD.t91 LOAD_EN3_N.t4 a_10284_6400.t0 VDD.t90 pfet_03v3 ad=5.2p pd=20.52u as=8.8p ps=40.88u w=20u l=0.28u
X48 a_7724_6400.t1 LOAD_EN3_N.t13 VDD.t77 VDD.t76 pfet_03v3 ad=5.2p pd=20.52u as=5.2p ps=20.52u w=20u l=0.28u
X49 VDD.t147 LOAD_EN2_N.t9 a_n4756_6400.t1 VDD.t146 pfet_03v3 ad=5.2p pd=20.52u as=8.8p ps=40.88u w=20u l=0.28u
X50 OUTN.t1 ODD_N.t1 a_n1292_n2000.t3 VSS.t3 nfet_03v3 ad=5.2p pd=20.52u as=5.2p ps=20.52u w=20u l=0.28u
X51 a_n1292_n2000.t7 ODD_P.t2 OUTP.t2 VSS.t8 nfet_03v3 ad=5.2p pd=20.52u as=5.2p ps=20.52u w=20u l=0.28u
X52 a_2604_6400.t0 OUTN.t10 VSS.t21 ppolyf_u r_width=1u r_length=0.8u
X53 a_7724_6400.t3 LOAD_EN3_N.t11 VDD.t75 VDD.t74 pfet_03v3 ad=5.2p pd=20.52u as=5.2p ps=20.52u w=20u l=0.28u
X54 VDD.t140 LOAD_EN1_N.t0 a_2604_6400.t5 VDD.t139 pfet_03v3 ad=8.8p pd=40.88u as=5.2p ps=20.52u w=20u l=0.28u
X55 VDD.t71 LOAD_EN3_N.t14 a_7724_6400.t0 VDD.t70 pfet_03v3 ad=5.2p pd=20.52u as=8.8p ps=40.88u w=20u l=0.28u
X56 VDD.t23 LOAD_EN3_N.t42 a_n9876_6400.t2 VDD.t22 pfet_03v3 ad=5.2p pd=20.52u as=5.2p ps=20.52u w=20u l=0.28u
X57 a_n4756_6400.t2 LOAD_EN2_N.t8 VDD.t143 VDD.t142 pfet_03v3 ad=5.2p pd=20.52u as=5.2p ps=20.52u w=20u l=0.28u
X58 a_n3292_n2000.t5 EVEN_N.t4 OUTN.t14 VSS.t61 nfet_03v3 ad=5.2p pd=20.52u as=8.8p ps=40.88u w=20u l=0.28u
X59 VDD.t79 LOAD_EN3_N.t12 a_7724_6400.t2 VDD.t78 pfet_03v3 ad=5.2p pd=20.52u as=5.2p ps=20.52u w=20u l=0.28u
X60 a_7724_6400.t5 OUTN.t6 VSS.t11 ppolyf_u r_width=1u r_length=0.8u
X61 a_n9876_6400.t3 LOAD_EN3_N.t41 VDD.t25 VDD.t24 pfet_03v3 ad=5.2p pd=20.52u as=5.2p ps=20.52u w=20u l=0.28u
X62 a_n6036_6400.t1 LOAD_EN3_N.t28 VDD.t45 VDD.t44 pfet_03v3 ad=5.2p pd=20.52u as=5.2p ps=20.52u w=20u l=0.28u
X63 a_n11156_6400.t3 LOAD_EN3_N.t46 VDD.t19 VDD.t18 pfet_03v3 ad=5.2p pd=20.52u as=5.2p ps=20.52u w=20u l=0.28u
X64 a_n11156_6400.t5 OUTP.t18 VSS.t59 ppolyf_u r_width=1u r_length=0.8u
X65 a_3884_6400.t4 LOAD_EN2_N.t1 VDD.t155 VDD.t154 pfet_03v3 ad=5.2p pd=20.52u as=5.2p ps=20.52u w=20u l=0.28u
X66 VDD.t47 LOAD_EN3_N.t27 a_n6036_6400.t2 VDD.t46 pfet_03v3 ad=5.2p pd=20.52u as=5.2p ps=20.52u w=20u l=0.28u
X67 a_9004_6400.t1 LOAD_EN3_N.t8 VDD.t85 VDD.t84 pfet_03v3 ad=5.2p pd=20.52u as=5.2p ps=20.52u w=20u l=0.28u
X68 VDD.t21 LOAD_EN3_N.t45 a_n11156_6400.t4 VDD.t20 pfet_03v3 ad=8.8p pd=40.88u as=5.2p ps=20.52u w=20u l=0.28u
X69 a_3884_6400.t0 OUTN.t9 VSS.t19 ppolyf_u r_width=1u r_length=0.8u
X70 VSS.t32 VBIAS.t13 a_n2292_n6800.t0 VSS.t31 nfet_03v3 ad=5.2p pd=20.52u as=8.8p ps=40.88u w=20u l=0.28u
X71 a_n2196_6400.t1 LOAD_EN0_N.t8 VDD.t102 VDD.t101 pfet_03v3 ad=5.2p pd=20.52u as=5.2p ps=20.52u w=20u l=0.28u
X72 VDD.t55 LOAD_EN3_N.t22 a_5164_6400.t2 VDD.t54 pfet_03v3 ad=5.2p pd=20.52u as=5.2p ps=20.52u w=20u l=0.28u
X73 a_n1292_n2000.t0 ODD_N.t4 OUTN.t4 VSS.t0 nfet_03v3 ad=5.2p pd=20.52u as=8.8p ps=40.88u w=20u l=0.28u
X74 VSS.t52 VBIAS.t3 a_n2292_n6800.t10 VSS.t51 nfet_03v3 ad=5.2p pd=20.52u as=5.2p ps=20.52u w=20u l=0.28u
X75 a_n7316_6400.t3 LOAD_EN3_N.t31 VDD.t41 VDD.t40 pfet_03v3 ad=5.2p pd=20.52u as=5.2p ps=20.52u w=20u l=0.28u
X76 a_n2292_n6800.t7 VBIAS.t6 VSS.t48 VSS.t47 nfet_03v3 ad=5.2p pd=20.52u as=5.2p ps=20.52u w=20u l=0.28u
X77 a_1324_6400.t3 LOAD_EN0_N.t1 VDD.t114 VDD.t113 pfet_03v3 ad=5.2p pd=20.52u as=5.2p ps=20.52u w=20u l=0.28u
X78 a_5164_6400.t1 LOAD_EN3_N.t23 VDD.t53 VDD.t52 pfet_03v3 ad=5.2p pd=20.52u as=5.2p ps=20.52u w=20u l=0.28u
X79 a_n7316_6400.t1 LOAD_EN3_N.t33 VDD.t3 VDD.t2 pfet_03v3 ad=5.2p pd=20.52u as=5.2p ps=20.52u w=20u l=0.28u
X80 VDD.t141 OUTN.t12 VSS.t25 ppolyf_u r_width=1u r_length=0.8u
X81 VDD.t104 LOAD_EN0_N.t9 a_n2196_6400.t0 VDD.t103 pfet_03v3 ad=5.2p pd=20.52u as=8.8p ps=40.88u w=20u l=0.28u
X82 a_n3292_n2000.t0 EVEN_P.t4 OUTP.t17 VSS.t26 nfet_03v3 ad=5.2p pd=20.52u as=8.8p ps=40.88u w=20u l=0.28u
X83 a_6444_6400.t1 LOAD_EN3_N.t18 VDD.t65 VDD.t64 pfet_03v3 ad=5.2p pd=20.52u as=5.2p ps=20.52u w=20u l=0.28u
X84 VDD.t126 LOAD_EN1_N.t9 a_n3476_6400.t1 VDD.t125 pfet_03v3 ad=5.2p pd=20.52u as=8.8p ps=40.88u w=20u l=0.28u
X85 VDD.t118 LOAD_EN0_N.t2 a_1324_6400.t2 VDD.t117 pfet_03v3 ad=5.2p pd=20.52u as=5.2p ps=20.52u w=20u l=0.28u
X86 VSS.t40 VBIAS.t9 a_n2292_n6800.t4 VSS.t39 nfet_03v3 ad=5.2p pd=20.52u as=5.2p ps=20.52u w=20u l=0.28u
X87 VDD.t120 LOAD_EN0_N.t0 a_1324_6400.t4 VDD.t119 pfet_03v3 ad=8.8p pd=40.88u as=5.2p ps=20.52u w=20u l=0.28u
X88 OUTP.t3 ODD_P.t1 a_n1292_n2000.t8 VSS.t9 nfet_03v3 ad=5.2p pd=20.52u as=5.2p ps=20.52u w=20u l=0.28u
X89 a_1324_6400.t5 OUTN.t11 VSS.t24 ppolyf_u r_width=1u r_length=0.8u
X90 VDD.t35 LOAD_EN3_N.t35 a_n8596_6400.t4 VDD.t34 pfet_03v3 ad=8.8p pd=40.88u as=5.2p ps=20.52u w=20u l=0.28u
X91 a_n1292_n2000.t5 ODD_P.t4 OUTP.t0 VSS.t6 nfet_03v3 ad=5.2p pd=20.52u as=8.8p ps=40.88u w=20u l=0.28u
X92 VDD.t31 LOAD_EN3_N.t37 a_n8596_6400.t2 VDD.t30 pfet_03v3 ad=5.2p pd=20.52u as=5.2p ps=20.52u w=20u l=0.28u
X93 a_n3476_6400.t4 LOAD_EN1_N.t6 VDD.t130 VDD.t129 pfet_03v3 ad=5.2p pd=20.52u as=5.2p ps=20.52u w=20u l=0.28u
X94 VDD.t61 LOAD_EN3_N.t19 a_6444_6400.t0 VDD.t60 pfet_03v3 ad=5.2p pd=20.52u as=8.8p ps=40.88u w=20u l=0.28u
X95 a_n3476_6400.t2 LOAD_EN1_N.t8 VDD.t124 VDD.t123 pfet_03v3 ad=5.2p pd=20.52u as=5.2p ps=20.52u w=20u l=0.28u
X96 OUTP.t15 EVEN_P.t1 a_n3292_n2000.t3 VSS.t29 nfet_03v3 ad=5.2p pd=20.52u as=5.2p ps=20.52u w=20u l=0.28u
X97 a_n3292_n2000.t7 EVEN_N.t2 OUTN.t16 VSS.t63 nfet_03v3 ad=5.2p pd=20.52u as=5.2p ps=20.52u w=20u l=0.28u
X98 a_2604_6400.t2 LOAD_EN1_N.t3 VDD.t134 VDD.t133 pfet_03v3 ad=5.2p pd=20.52u as=5.2p ps=20.52u w=20u l=0.28u
X99 a_n8596_6400.t3 LOAD_EN3_N.t36 VDD.t33 VDD.t32 pfet_03v3 ad=5.2p pd=20.52u as=5.2p ps=20.52u w=20u l=0.28u
X100 a_n2292_n6800.t1 VBIAS.t12 VSS.t36 VSS.t35 nfet_03v3 ad=5.2p pd=20.52u as=5.2p ps=20.52u w=20u l=0.28u
X101 a_n1292_n2000.t11 CLK_N.t3 a_n2292_n6800.t14 VSS.t67 nfet_03v3 ad=5.2p pd=20.52u as=5.2p ps=20.52u w=20u l=0.28u
X102 a_n2292_n6800.t21 CLK_P.t0 a_n3292_n2000.t14 VSS.t75 nfet_03v3 ad=8.8p pd=40.88u as=5.2p ps=20.52u w=20u l=0.28u
X103 a_2604_6400.t4 LOAD_EN1_N.t1 VDD.t138 VDD.t137 pfet_03v3 ad=5.2p pd=20.52u as=5.2p ps=20.52u w=20u l=0.28u
X104 VDD.t149 LOAD_EN2_N.t7 a_n4756_6400.t3 VDD.t148 pfet_03v3 ad=5.2p pd=20.52u as=5.2p ps=20.52u w=20u l=0.28u
X105 a_n9876_6400.t5 OUTP.t11 VSS.t22 ppolyf_u r_width=1u r_length=0.8u
X106 VDD.t136 LOAD_EN1_N.t2 a_2604_6400.t3 VDD.t135 pfet_03v3 ad=5.2p pd=20.52u as=5.2p ps=20.52u w=20u l=0.28u
X107 VDD.t145 LOAD_EN2_N.t4 a_3884_6400.t1 VDD.t144 pfet_03v3 ad=5.2p pd=20.52u as=8.8p ps=40.88u w=20u l=0.28u
X108 VDD.t27 LOAD_EN3_N.t40 a_n9876_6400.t4 VDD.t26 pfet_03v3 ad=8.8p pd=40.88u as=5.2p ps=20.52u w=20u l=0.28u
X109 a_10284_6400.t3 LOAD_EN3_N.t1 VDD.t93 VDD.t92 pfet_03v3 ad=5.2p pd=20.52u as=5.2p ps=20.52u w=20u l=0.28u
X110 VDD.t159 LOAD_EN2_N.t2 a_3884_6400.t3 VDD.t158 pfet_03v3 ad=5.2p pd=20.52u as=5.2p ps=20.52u w=20u l=0.28u
X111 a_n6036_6400.t3 LOAD_EN3_N.t26 VDD.t49 VDD.t48 pfet_03v3 ad=5.2p pd=20.52u as=5.2p ps=20.52u w=20u l=0.28u
X112 a_n1292_n2000.t2 ODD_N.t2 OUTN.t0 VSS.t2 nfet_03v3 ad=5.2p pd=20.52u as=5.2p ps=20.52u w=20u l=0.28u
X113 VDD.t81 LOAD_EN3_N.t9 a_9004_6400.t0 VDD.t80 pfet_03v3 ad=5.2p pd=20.52u as=8.8p ps=40.88u w=20u l=0.28u
X114 a_3884_6400.t2 LOAD_EN2_N.t3 VDD.t157 VDD.t156 pfet_03v3 ad=5.2p pd=20.52u as=5.2p ps=20.52u w=20u l=0.28u
X115 a_n3292_n2000.t9 EVEN_N.t0 OUTN.t18 VSS.t65 nfet_03v3 ad=8.8p pd=40.88u as=5.2p ps=20.52u w=20u l=0.28u
X116 OUTP.t16 EVEN_P.t3 a_n3292_n2000.t1 VSS.t27 nfet_03v3 ad=5.2p pd=20.52u as=5.2p ps=20.52u w=20u l=0.28u
X117 VSS.t50 VBIAS.t5 a_n2292_n6800.t8 VSS.t49 nfet_03v3 ad=5.2p pd=20.52u as=5.2p ps=20.52u w=20u l=0.28u
X118 a_n2292_n6800.t22 CLK_P.t2 a_n3292_n2000.t12 VSS.t73 nfet_03v3 ad=5.2p pd=20.52u as=5.2p ps=20.52u w=20u l=0.28u
X119 a_10284_6400.t5 OUTN.t13 VSS.t60 ppolyf_u r_width=1u r_length=0.8u
X120 VDD.t99 LOAD_EN3_N.t0 a_10284_6400.t4 VDD.t98 pfet_03v3 ad=8.8p pd=40.88u as=5.2p ps=20.52u w=20u l=0.28u
X121 a_n1292_n2000.t13 CLK_N.t1 a_n2292_n6800.t16 VSS.t69 nfet_03v3 ad=5.2p pd=20.52u as=5.2p ps=20.52u w=20u l=0.28u
X122 VDD.t106 LOAD_EN0_N.t7 a_n2196_6400.t2 VDD.t105 pfet_03v3 ad=5.2p pd=20.52u as=5.2p ps=20.52u w=20u l=0.28u
X123 a_n2292_n6800.t13 VBIAS.t0 VSS.t58 VSS.t57 nfet_03v3 ad=8.8p pd=40.88u as=5.2p ps=20.52u w=20u l=0.28u
X124 a_n7316_6400.t5 OUTP.t9 VSS.t18 ppolyf_u r_width=1u r_length=0.8u
X125 VDD.t51 LOAD_EN3_N.t25 a_n6036_6400.t4 VDD.t50 pfet_03v3 ad=8.8p pd=40.88u as=5.2p ps=20.52u w=20u l=0.28u
X126 OUTP.t1 ODD_P.t3 a_n1292_n2000.t6 VSS.t7 nfet_03v3 ad=5.2p pd=20.52u as=5.2p ps=20.52u w=20u l=0.28u
X127 VDD.t100 OUTP.t6 VSS.t14 ppolyf_u r_width=1u r_length=0.8u
X128 a_n1292_n2000.t4 ODD_N.t0 OUTN.t2 VSS.t4 nfet_03v3 ad=8.8p pd=40.88u as=5.2p ps=20.52u w=20u l=0.28u
X129 VDD.t43 LOAD_EN3_N.t30 a_n7316_6400.t4 VDD.t42 pfet_03v3 ad=8.8p pd=40.88u as=5.2p ps=20.52u w=20u l=0.28u
X130 a_n2196_6400.t3 LOAD_EN0_N.t6 VDD.t108 VDD.t107 pfet_03v3 ad=5.2p pd=20.52u as=5.2p ps=20.52u w=20u l=0.28u
X131 VSS.t46 VBIAS.t7 a_n2292_n6800.t6 VSS.t45 nfet_03v3 ad=5.2p pd=20.52u as=5.2p ps=20.52u w=20u l=0.28u
X132 VDD.t1 LOAD_EN3_N.t24 a_5164_6400.t0 VDD.t0 pfet_03v3 ad=5.2p pd=20.52u as=8.8p ps=40.88u w=20u l=0.28u
X133 VDD.t89 LOAD_EN3_N.t5 a_9004_6400.t4 VDD.t88 pfet_03v3 ad=8.8p pd=40.88u as=5.2p ps=20.52u w=20u l=0.28u
X134 a_n11156_6400.t1 LOAD_EN3_N.t48 VDD.t5 VDD.t4 pfet_03v3 ad=5.2p pd=20.52u as=5.2p ps=20.52u w=20u l=0.28u
X135 a_n2292_n6800.t18 CLK_N.t4 a_n1292_n2000.t10 VSS.t66 nfet_03v3 ad=5.2p pd=20.52u as=8.8p ps=40.88u w=20u l=0.28u
X136 a_1324_6400.t1 LOAD_EN0_N.t3 VDD.t116 VDD.t115 pfet_03v3 ad=5.2p pd=20.52u as=5.2p ps=20.52u w=20u l=0.28u
X137 VDD.t132 LOAD_EN1_N.t5 a_n3476_6400.t5 VDD.t131 pfet_03v3 ad=8.8p pd=40.88u as=5.2p ps=20.52u w=20u l=0.28u
X138 VDD.t128 LOAD_EN1_N.t7 a_n3476_6400.t3 VDD.t127 pfet_03v3 ad=5.2p pd=20.52u as=5.2p ps=20.52u w=20u l=0.28u
X139 VDD.t112 LOAD_EN0_N.t4 a_1324_6400.t0 VDD.t111 pfet_03v3 ad=5.2p pd=20.52u as=8.8p ps=40.88u w=20u l=0.28u
X140 a_n8596_6400.t5 OUTP.t5 VSS.t12 ppolyf_u r_width=1u r_length=0.8u
X141 VDD.t122 LOAD_EN1_N.t4 a_2604_6400.t1 VDD.t121 pfet_03v3 ad=5.2p pd=20.52u as=8.8p ps=40.88u w=20u l=0.28u
R0 VBIAS.n5 VBIAS.t0 270.06
R1 VBIAS.n16 VBIAS.t13 270.06
R2 VBIAS.n6 VBIAS.t1 265.603
R3 VBIAS.n7 VBIAS.t2 265.603
R4 VBIAS.n8 VBIAS.t3 265.603
R5 VBIAS.n9 VBIAS.t4 265.603
R6 VBIAS.n10 VBIAS.t5 265.603
R7 VBIAS.n11 VBIAS.t6 265.603
R8 VBIAS.n12 VBIAS.t7 265.603
R9 VBIAS.n21 VBIAS.t8 265.603
R10 VBIAS.n20 VBIAS.t9 265.603
R11 VBIAS.n19 VBIAS.t10 265.603
R12 VBIAS.n14 VBIAS.t11 265.603
R13 VBIAS.n15 VBIAS.t12 265.603
R14 VBIAS.n7 VBIAS.n4 18.4942
R15 VBIAS.n8 VBIAS.n3 18.4942
R16 VBIAS.n9 VBIAS.n2 18.4942
R17 VBIAS.n10 VBIAS.n1 18.4942
R18 VBIAS.n11 VBIAS.n0 18.4942
R19 VBIAS VBIAS.n12 18.4942
R20 VBIAS.n22 VBIAS.n21 18.4942
R21 VBIAS.n20 VBIAS.n13 18.4942
R22 VBIAS.n19 VBIAS.n18 18.4942
R23 VBIAS.n17 VBIAS.n14 18.4942
R24 VBIAS.n7 VBIAS.n6 11.6805
R25 VBIAS.n8 VBIAS.n7 11.6805
R26 VBIAS.n9 VBIAS.n8 11.6805
R27 VBIAS.n10 VBIAS.n9 11.6805
R28 VBIAS.n11 VBIAS.n10 11.6805
R29 VBIAS.n12 VBIAS.n11 11.6805
R30 VBIAS.n21 VBIAS.n12 11.6805
R31 VBIAS.n21 VBIAS.n20 11.6805
R32 VBIAS.n20 VBIAS.n19 11.6805
R33 VBIAS.n19 VBIAS.n14 11.6805
R34 VBIAS.n15 VBIAS.n14 11.6805
R35 VBIAS.n17 VBIAS.n16 7.17687
R36 VBIAS.n5 VBIAS.n4 7.17687
R37 VBIAS.n6 VBIAS.n5 4.42851
R38 VBIAS.n16 VBIAS.n15 4.42851
R39 VBIAS.n18 VBIAS.n17 0.1205
R40 VBIAS.n18 VBIAS.n13 0.1205
R41 VBIAS.n22 VBIAS.n13 0.1205
R42 VBIAS VBIAS.n22 0.1205
R43 VBIAS VBIAS.n0 0.1205
R44 VBIAS.n1 VBIAS.n0 0.1205
R45 VBIAS.n2 VBIAS.n1 0.1205
R46 VBIAS.n3 VBIAS.n2 0.1205
R47 VBIAS.n4 VBIAS.n3 0.1205
R48 CLK_N.n2 CLK_N.t0 270.06
R49 CLK_N.n3 CLK_N.t1 265.603
R50 CLK_N.n4 CLK_N.t2 265.603
R51 CLK_N.n5 CLK_N.t3 265.603
R52 CLK_N.n6 CLK_N.t4 265.603
R53 CLK_N.n4 CLK_N.n1 18.4942
R54 CLK_N.n5 CLK_N.n0 18.4942
R55 CLK_N.n7 CLK_N.n6 18.4942
R56 CLK_N.n4 CLK_N.n3 11.6805
R57 CLK_N.n5 CLK_N.n4 11.6805
R58 CLK_N.n6 CLK_N.n5 11.6805
R59 CLK_N.n2 CLK_N.n1 7.17687
R60 CLK_N.n3 CLK_N.n2 4.42851
R61 CLK_N.n7 CLK_N.n0 0.1205
R62 CLK_N.n1 CLK_N.n0 0.1205
R63 CLK_N CLK_N.n7 0.053
R64 CLK_P.n2 CLK_P.t0 270.06
R65 CLK_P.n3 CLK_P.t1 265.603
R66 CLK_P.n4 CLK_P.t2 265.603
R67 CLK_P.n5 CLK_P.t3 265.603
R68 CLK_P.n6 CLK_P.t4 265.603
R69 CLK_P.n4 CLK_P.n1 18.4942
R70 CLK_P.n5 CLK_P.n0 18.4942
R71 CLK_P.n7 CLK_P.n6 18.4942
R72 CLK_P.n4 CLK_P.n3 11.6805
R73 CLK_P.n5 CLK_P.n4 11.6805
R74 CLK_P.n6 CLK_P.n5 11.6805
R75 CLK_P.n2 CLK_P.n1 7.17687
R76 CLK_P.n3 CLK_P.n2 4.42851
R77 CLK_P.n7 CLK_P.n0 0.1205
R78 CLK_P.n1 CLK_P.n0 0.1205
R79 CLK_P CLK_P.n7 0.053
R80 EVEN_N.n2 EVEN_N.t0 270.06
R81 EVEN_N.n3 EVEN_N.t1 265.603
R82 EVEN_N.n4 EVEN_N.t2 265.603
R83 EVEN_N.n5 EVEN_N.t3 265.603
R84 EVEN_N.n6 EVEN_N.t4 265.603
R85 EVEN_N.n4 EVEN_N.n1 18.4942
R86 EVEN_N.n5 EVEN_N.n0 18.4942
R87 EVEN_N.n7 EVEN_N.n6 18.4942
R88 EVEN_N.n4 EVEN_N.n3 11.6805
R89 EVEN_N.n5 EVEN_N.n4 11.6805
R90 EVEN_N.n6 EVEN_N.n5 11.6805
R91 EVEN_N.n2 EVEN_N.n1 7.17687
R92 EVEN_N.n3 EVEN_N.n2 4.42851
R93 EVEN_N.n7 EVEN_N.n0 0.1205
R94 EVEN_N.n1 EVEN_N.n0 0.1205
R95 EVEN_N EVEN_N.n7 0.053
R96 ODD_N.n2 ODD_N.t0 270.06
R97 ODD_N.n3 ODD_N.t1 265.603
R98 ODD_N.n4 ODD_N.t2 265.603
R99 ODD_N.n5 ODD_N.t3 265.603
R100 ODD_N.n6 ODD_N.t4 265.603
R101 ODD_N.n4 ODD_N.n1 18.4942
R102 ODD_N.n5 ODD_N.n0 18.4942
R103 ODD_N.n7 ODD_N.n6 18.4942
R104 ODD_N.n4 ODD_N.n3 11.6805
R105 ODD_N.n5 ODD_N.n4 11.6805
R106 ODD_N.n6 ODD_N.n5 11.6805
R107 ODD_N.n2 ODD_N.n1 7.17687
R108 ODD_N.n3 ODD_N.n2 4.42851
R109 ODD_N.n7 ODD_N.n0 0.1205
R110 ODD_N.n1 ODD_N.n0 0.1205
R111 ODD_N ODD_N.n7 0.053
R112 ODD_P.n2 ODD_P.t0 270.06
R113 ODD_P.n3 ODD_P.t1 265.603
R114 ODD_P.n4 ODD_P.t2 265.603
R115 ODD_P.n5 ODD_P.t3 265.603
R116 ODD_P.n6 ODD_P.t4 265.603
R117 ODD_P.n4 ODD_P.n1 18.4942
R118 ODD_P.n5 ODD_P.n0 18.4942
R119 ODD_P.n7 ODD_P.n6 18.4942
R120 ODD_P.n4 ODD_P.n3 11.6805
R121 ODD_P.n5 ODD_P.n4 11.6805
R122 ODD_P.n6 ODD_P.n5 11.6805
R123 ODD_P.n2 ODD_P.n1 7.17687
R124 ODD_P.n3 ODD_P.n2 4.42851
R125 ODD_P.n7 ODD_P.n0 0.1205
R126 ODD_P.n1 ODD_P.n0 0.1205
R127 ODD_P ODD_P.n7 0.053
R128 EVEN_P.n2 EVEN_P.t0 270.06
R129 EVEN_P.n3 EVEN_P.t1 265.603
R130 EVEN_P.n4 EVEN_P.t2 265.603
R131 EVEN_P.n5 EVEN_P.t3 265.603
R132 EVEN_P.n6 EVEN_P.t4 265.603
R133 EVEN_P.n4 EVEN_P.n1 18.4942
R134 EVEN_P.n5 EVEN_P.n0 18.4942
R135 EVEN_P.n7 EVEN_P.n6 18.4942
R136 EVEN_P.n4 EVEN_P.n3 11.6805
R137 EVEN_P.n5 EVEN_P.n4 11.6805
R138 EVEN_P.n6 EVEN_P.n5 11.6805
R139 EVEN_P.n2 EVEN_P.n1 7.17687
R140 EVEN_P.n3 EVEN_P.n2 4.42851
R141 EVEN_P.n7 EVEN_P.n0 0.1205
R142 EVEN_P.n1 EVEN_P.n0 0.1205
R143 EVEN_P EVEN_P.n7 0.053
R144 OUTN.n0 OUTN.t12 15.8895
R145 OUTN.n0 OUTN.t13 15.4095
R146 OUTN.n1 OUTN.t5 15.4095
R147 OUTN.n2 OUTN.t6 15.4095
R148 OUTN.n3 OUTN.t7 15.4095
R149 OUTN.n4 OUTN.t8 15.4095
R150 OUTN.n5 OUTN.t9 15.4095
R151 OUTN.n6 OUTN.t10 15.4095
R152 OUTN.n7 OUTN.t11 15.4095
R153 OUTN.n8 OUTN.t4 7.86957
R154 OUTN.n15 OUTN.n14 7.78767
R155 OUTN.n18 OUTN.t14 7.77479
R156 OUTN.n12 OUTN.n9 7.69289
R157 OUTN.n11 OUTN.n10 7.69289
R158 OUTN.n17 OUTN.n16 7.69289
R159 OUTN.n19 OUTN.n18 4.5005
R160 OUTN.n13 OUTN.n12 4.5005
R161 OUTN.n19 OUTN.n15 2.38404
R162 OUTN.n13 OUTN.n8 2.38404
R163 OUTN.n6 OUTN.n5 0.4805
R164 OUTN.n5 OUTN.n4 0.4805
R165 OUTN.n4 OUTN.n3 0.4805
R166 OUTN.n3 OUTN.n2 0.4805
R167 OUTN.n2 OUTN.n1 0.4805
R168 OUTN.n1 OUTN.n0 0.4805
R169 OUTN.n7 OUTN.n6 0.413
R170 OUTN OUTN.n7 0.386214
R171 OUTN.n20 OUTN.n19 0.2975
R172 OUTN.n12 OUTN.n11 0.189974
R173 OUTN.n18 OUTN.n17 0.189974
R174 OUTN.n20 OUTN.n13 0.1895
R175 OUTN.n17 OUTN.n15 0.092352
R176 OUTN.n11 OUTN.n8 0.092352
R177 OUTN.n9 OUTN.t1 0.0824
R178 OUTN.n9 OUTN.t2 0.0824
R179 OUTN.n10 OUTN.t3 0.0824
R180 OUTN.n10 OUTN.t0 0.0824
R181 OUTN.n14 OUTN.t17 0.0824
R182 OUTN.n14 OUTN.t18 0.0824
R183 OUTN.n16 OUTN.t15 0.0824
R184 OUTN.n16 OUTN.t16 0.0824
R185 OUTN OUTN.n20 0.0647857
R186 OUTP.n0 OUTP.t6 15.8895
R187 OUTP.n6 OUTP.t10 15.4095
R188 OUTP.n5 OUTP.t7 15.4095
R189 OUTP.n4 OUTP.t8 15.4095
R190 OUTP.n3 OUTP.t9 15.4095
R191 OUTP.n2 OUTP.t5 15.4095
R192 OUTP.n1 OUTP.t11 15.4095
R193 OUTP.n0 OUTP.t18 15.4095
R194 OUTP.n7 OUTP.t12 15.4095
R195 OUTP.n8 OUTP.t17 7.86957
R196 OUTP.n15 OUTP.n14 7.78767
R197 OUTP.n18 OUTP.t0 7.77479
R198 OUTP.n12 OUTP.n9 7.69289
R199 OUTP.n11 OUTP.n10 7.69289
R200 OUTP.n17 OUTP.n16 7.69289
R201 OUTP.n19 OUTP.n18 4.5005
R202 OUTP.n13 OUTP.n12 4.5005
R203 OUTP.n19 OUTP.n15 2.38404
R204 OUTP.n13 OUTP.n8 2.38404
R205 OUTP.n1 OUTP.n0 0.4805
R206 OUTP.n2 OUTP.n1 0.4805
R207 OUTP.n3 OUTP.n2 0.4805
R208 OUTP.n4 OUTP.n3 0.4805
R209 OUTP.n5 OUTP.n4 0.4805
R210 OUTP.n6 OUTP.n5 0.4805
R211 OUTP.n7 OUTP.n6 0.413
R212 OUTP OUTP.n7 0.386214
R213 OUTP.n20 OUTP.n13 0.3695
R214 OUTP.n12 OUTP.n11 0.189974
R215 OUTP.n18 OUTP.n17 0.189974
R216 OUTP.n20 OUTP.n19 0.1175
R217 OUTP.n17 OUTP.n15 0.092352
R218 OUTP.n11 OUTP.n8 0.092352
R219 OUTP.n9 OUTP.t15 0.0824
R220 OUTP.n9 OUTP.t13 0.0824
R221 OUTP.n10 OUTP.t16 0.0824
R222 OUTP.n10 OUTP.t14 0.0824
R223 OUTP.n14 OUTP.t3 0.0824
R224 OUTP.n14 OUTP.t4 0.0824
R225 OUTP.n16 OUTP.t1 0.0824
R226 OUTP.n16 OUTP.t2 0.0824
R227 OUTP OUTP.n20 0.0647857
R228 LOAD_EN0_N.n6 LOAD_EN0_N.t4 270.06
R229 LOAD_EN0_N.n2 LOAD_EN0_N.t0 270.06
R230 LOAD_EN0_N.n10 LOAD_EN0_N.t5 270.06
R231 LOAD_EN0_N.n11 LOAD_EN0_N.t9 270.06
R232 LOAD_EN0_N.n5 LOAD_EN0_N.t3 265.603
R233 LOAD_EN0_N.n4 LOAD_EN0_N.t2 265.603
R234 LOAD_EN0_N.n3 LOAD_EN0_N.t1 265.603
R235 LOAD_EN0_N.n13 LOAD_EN0_N.t6 265.603
R236 LOAD_EN0_N.n14 LOAD_EN0_N.t7 265.603
R237 LOAD_EN0_N.n12 LOAD_EN0_N.t8 265.603
R238 LOAD_EN0_N.n4 LOAD_EN0_N.n1 18.4942
R239 LOAD_EN0_N.n15 LOAD_EN0_N.n14 18.4942
R240 LOAD_EN0_N.n5 LOAD_EN0_N.n4 11.6805
R241 LOAD_EN0_N.n4 LOAD_EN0_N.n3 11.6805
R242 LOAD_EN0_N.n14 LOAD_EN0_N.n13 11.6805
R243 LOAD_EN0_N.n14 LOAD_EN0_N.n12 11.6805
R244 LOAD_EN0_N.n7 LOAD_EN0_N.n6 7.12887
R245 LOAD_EN0_N.n2 LOAD_EN0_N.n0 7.12887
R246 LOAD_EN0_N.n11 LOAD_EN0_N.n9 7.12887
R247 LOAD_EN0_N.n16 LOAD_EN0_N.n10 7.12887
R248 LOAD_EN0_N.n8 LOAD_EN0_N.n0 4.5725
R249 LOAD_EN0_N.n17 LOAD_EN0_N.n9 4.5725
R250 LOAD_EN0_N.n8 LOAD_EN0_N.n7 4.5005
R251 LOAD_EN0_N.n17 LOAD_EN0_N.n16 4.5005
R252 LOAD_EN0_N.n6 LOAD_EN0_N.n5 4.42851
R253 LOAD_EN0_N.n3 LOAD_EN0_N.n2 4.42851
R254 LOAD_EN0_N.n13 LOAD_EN0_N.n10 4.42851
R255 LOAD_EN0_N.n12 LOAD_EN0_N.n11 4.42851
R256 LOAD_EN0_N LOAD_EN0_N.n8 1.14495
R257 LOAD_EN0_N LOAD_EN0_N.n17 1.02923
R258 LOAD_EN0_N.n7 LOAD_EN0_N.n1 0.0485
R259 LOAD_EN0_N.n1 LOAD_EN0_N.n0 0.0485
R260 LOAD_EN0_N.n15 LOAD_EN0_N.n9 0.0485
R261 LOAD_EN0_N.n16 LOAD_EN0_N.n15 0.0485
R262 LOAD_EN1_N.n3 LOAD_EN1_N.t4 270.06
R263 LOAD_EN1_N.n1 LOAD_EN1_N.t0 270.06
R264 LOAD_EN1_N.n10 LOAD_EN1_N.t5 270.06
R265 LOAD_EN1_N.n11 LOAD_EN1_N.t9 270.06
R266 LOAD_EN1_N.n4 LOAD_EN1_N.t3 265.603
R267 LOAD_EN1_N.n5 LOAD_EN1_N.t2 265.603
R268 LOAD_EN1_N.n2 LOAD_EN1_N.t1 265.603
R269 LOAD_EN1_N.n13 LOAD_EN1_N.t6 265.603
R270 LOAD_EN1_N.n14 LOAD_EN1_N.t7 265.603
R271 LOAD_EN1_N.n12 LOAD_EN1_N.t8 265.603
R272 LOAD_EN1_N.n6 LOAD_EN1_N.n5 18.4942
R273 LOAD_EN1_N.n15 LOAD_EN1_N.n14 18.4942
R274 LOAD_EN1_N.n5 LOAD_EN1_N.n4 11.6805
R275 LOAD_EN1_N.n5 LOAD_EN1_N.n2 11.6805
R276 LOAD_EN1_N.n14 LOAD_EN1_N.n13 11.6805
R277 LOAD_EN1_N.n14 LOAD_EN1_N.n12 11.6805
R278 LOAD_EN1_N.n3 LOAD_EN1_N.n0 7.12887
R279 LOAD_EN1_N.n7 LOAD_EN1_N.n1 7.12887
R280 LOAD_EN1_N.n11 LOAD_EN1_N.n9 7.12887
R281 LOAD_EN1_N.n16 LOAD_EN1_N.n10 7.12887
R282 LOAD_EN1_N LOAD_EN1_N.n8 5.50402
R283 LOAD_EN1_N.n8 LOAD_EN1_N.n7 4.537
R284 LOAD_EN1_N.n17 LOAD_EN1_N.n9 4.537
R285 LOAD_EN1_N.n8 LOAD_EN1_N.n0 4.53643
R286 LOAD_EN1_N.n17 LOAD_EN1_N.n16 4.53643
R287 LOAD_EN1_N.n4 LOAD_EN1_N.n3 4.42851
R288 LOAD_EN1_N.n2 LOAD_EN1_N.n1 4.42851
R289 LOAD_EN1_N.n13 LOAD_EN1_N.n10 4.42851
R290 LOAD_EN1_N.n12 LOAD_EN1_N.n11 4.42851
R291 LOAD_EN1_N LOAD_EN1_N.n17 2.81688
R292 LOAD_EN1_N.n6 LOAD_EN1_N.n0 0.0485
R293 LOAD_EN1_N.n7 LOAD_EN1_N.n6 0.0485
R294 LOAD_EN1_N.n15 LOAD_EN1_N.n9 0.0485
R295 LOAD_EN1_N.n16 LOAD_EN1_N.n15 0.0485
R296 LOAD_EN2_N.n6 LOAD_EN2_N.t4 270.06
R297 LOAD_EN2_N.n2 LOAD_EN2_N.t0 270.06
R298 LOAD_EN2_N.n10 LOAD_EN2_N.t5 270.06
R299 LOAD_EN2_N.n11 LOAD_EN2_N.t9 270.06
R300 LOAD_EN2_N.n5 LOAD_EN2_N.t3 265.603
R301 LOAD_EN2_N.n4 LOAD_EN2_N.t2 265.603
R302 LOAD_EN2_N.n3 LOAD_EN2_N.t1 265.603
R303 LOAD_EN2_N.n13 LOAD_EN2_N.t6 265.603
R304 LOAD_EN2_N.n14 LOAD_EN2_N.t7 265.603
R305 LOAD_EN2_N.n12 LOAD_EN2_N.t8 265.603
R306 LOAD_EN2_N.n4 LOAD_EN2_N.n1 18.4942
R307 LOAD_EN2_N.n15 LOAD_EN2_N.n14 18.4942
R308 LOAD_EN2_N.n5 LOAD_EN2_N.n4 11.6805
R309 LOAD_EN2_N.n4 LOAD_EN2_N.n3 11.6805
R310 LOAD_EN2_N.n14 LOAD_EN2_N.n13 11.6805
R311 LOAD_EN2_N.n14 LOAD_EN2_N.n12 11.6805
R312 LOAD_EN2_N LOAD_EN2_N.n17 8.46191
R313 LOAD_EN2_N.n7 LOAD_EN2_N.n6 7.12887
R314 LOAD_EN2_N.n2 LOAD_EN2_N.n0 7.12887
R315 LOAD_EN2_N.n11 LOAD_EN2_N.n9 7.12887
R316 LOAD_EN2_N.n16 LOAD_EN2_N.n10 7.12887
R317 LOAD_EN2_N LOAD_EN2_N.n8 6.0062
R318 LOAD_EN2_N.n8 LOAD_EN2_N.n0 4.53672
R319 LOAD_EN2_N.n17 LOAD_EN2_N.n9 4.53672
R320 LOAD_EN2_N.n8 LOAD_EN2_N.n7 4.53671
R321 LOAD_EN2_N.n17 LOAD_EN2_N.n16 4.53671
R322 LOAD_EN2_N.n6 LOAD_EN2_N.n5 4.42851
R323 LOAD_EN2_N.n3 LOAD_EN2_N.n2 4.42851
R324 LOAD_EN2_N.n13 LOAD_EN2_N.n10 4.42851
R325 LOAD_EN2_N.n12 LOAD_EN2_N.n11 4.42851
R326 LOAD_EN2_N.n7 LOAD_EN2_N.n1 0.0485
R327 LOAD_EN2_N.n1 LOAD_EN2_N.n0 0.0485
R328 LOAD_EN2_N.n15 LOAD_EN2_N.n9 0.0485
R329 LOAD_EN2_N.n16 LOAD_EN2_N.n15 0.0485
R330 LOAD_EN3_N.n0 LOAD_EN3_N.t0 270.06
R331 LOAD_EN3_N.n4 LOAD_EN3_N.t4 270.06
R332 LOAD_EN3_N.n6 LOAD_EN3_N.t5 270.06
R333 LOAD_EN3_N.n10 LOAD_EN3_N.t9 270.06
R334 LOAD_EN3_N.n13 LOAD_EN3_N.t10 270.06
R335 LOAD_EN3_N.n17 LOAD_EN3_N.t14 270.06
R336 LOAD_EN3_N.n20 LOAD_EN3_N.t15 270.06
R337 LOAD_EN3_N.n24 LOAD_EN3_N.t19 270.06
R338 LOAD_EN3_N.n37 LOAD_EN3_N.t24 270.06
R339 LOAD_EN3_N.n33 LOAD_EN3_N.t20 270.06
R340 LOAD_EN3_N.n43 LOAD_EN3_N.t45 270.06
R341 LOAD_EN3_N.n47 LOAD_EN3_N.t49 270.06
R342 LOAD_EN3_N.n49 LOAD_EN3_N.t40 270.06
R343 LOAD_EN3_N.n53 LOAD_EN3_N.t44 270.06
R344 LOAD_EN3_N.n56 LOAD_EN3_N.t35 270.06
R345 LOAD_EN3_N.n60 LOAD_EN3_N.t39 270.06
R346 LOAD_EN3_N.n63 LOAD_EN3_N.t30 270.06
R347 LOAD_EN3_N.n67 LOAD_EN3_N.t34 270.06
R348 LOAD_EN3_N.n79 LOAD_EN3_N.t29 270.06
R349 LOAD_EN3_N.n75 LOAD_EN3_N.t25 270.06
R350 LOAD_EN3_N.n1 LOAD_EN3_N.t1 265.603
R351 LOAD_EN3_N.n2 LOAD_EN3_N.t2 265.603
R352 LOAD_EN3_N.n3 LOAD_EN3_N.t3 265.603
R353 LOAD_EN3_N.n7 LOAD_EN3_N.t6 265.603
R354 LOAD_EN3_N.n8 LOAD_EN3_N.t7 265.603
R355 LOAD_EN3_N.n9 LOAD_EN3_N.t8 265.603
R356 LOAD_EN3_N.n14 LOAD_EN3_N.t11 265.603
R357 LOAD_EN3_N.n15 LOAD_EN3_N.t12 265.603
R358 LOAD_EN3_N.n16 LOAD_EN3_N.t13 265.603
R359 LOAD_EN3_N.n21 LOAD_EN3_N.t16 265.603
R360 LOAD_EN3_N.n22 LOAD_EN3_N.t17 265.603
R361 LOAD_EN3_N.n23 LOAD_EN3_N.t18 265.603
R362 LOAD_EN3_N.n36 LOAD_EN3_N.t23 265.603
R363 LOAD_EN3_N.n35 LOAD_EN3_N.t22 265.603
R364 LOAD_EN3_N.n34 LOAD_EN3_N.t21 265.603
R365 LOAD_EN3_N.n44 LOAD_EN3_N.t46 265.603
R366 LOAD_EN3_N.n45 LOAD_EN3_N.t47 265.603
R367 LOAD_EN3_N.n46 LOAD_EN3_N.t48 265.603
R368 LOAD_EN3_N.n50 LOAD_EN3_N.t41 265.603
R369 LOAD_EN3_N.n51 LOAD_EN3_N.t42 265.603
R370 LOAD_EN3_N.n52 LOAD_EN3_N.t43 265.603
R371 LOAD_EN3_N.n57 LOAD_EN3_N.t36 265.603
R372 LOAD_EN3_N.n58 LOAD_EN3_N.t37 265.603
R373 LOAD_EN3_N.n59 LOAD_EN3_N.t38 265.603
R374 LOAD_EN3_N.n64 LOAD_EN3_N.t31 265.603
R375 LOAD_EN3_N.n65 LOAD_EN3_N.t32 265.603
R376 LOAD_EN3_N.n66 LOAD_EN3_N.t33 265.603
R377 LOAD_EN3_N.n78 LOAD_EN3_N.t28 265.603
R378 LOAD_EN3_N.n77 LOAD_EN3_N.t27 265.603
R379 LOAD_EN3_N.n76 LOAD_EN3_N.t26 265.603
R380 LOAD_EN3_N.n5 LOAD_EN3_N.n2 18.4942
R381 LOAD_EN3_N.n11 LOAD_EN3_N.n8 18.4942
R382 LOAD_EN3_N.n18 LOAD_EN3_N.n15 18.4942
R383 LOAD_EN3_N.n25 LOAD_EN3_N.n22 18.4942
R384 LOAD_EN3_N.n35 LOAD_EN3_N.n31 18.4942
R385 LOAD_EN3_N.n48 LOAD_EN3_N.n45 18.4942
R386 LOAD_EN3_N.n54 LOAD_EN3_N.n51 18.4942
R387 LOAD_EN3_N.n61 LOAD_EN3_N.n58 18.4942
R388 LOAD_EN3_N.n68 LOAD_EN3_N.n65 18.4942
R389 LOAD_EN3_N.n77 LOAD_EN3_N.n73 18.4942
R390 LOAD_EN3_N.n12 LOAD_EN3_N.n5 18.3628
R391 LOAD_EN3_N.n55 LOAD_EN3_N.n48 18.3628
R392 LOAD_EN3_N.n12 LOAD_EN3_N.n11 18.0005
R393 LOAD_EN3_N.n19 LOAD_EN3_N.n18 18.0005
R394 LOAD_EN3_N.n26 LOAD_EN3_N.n25 18.0005
R395 LOAD_EN3_N.n55 LOAD_EN3_N.n54 18.0005
R396 LOAD_EN3_N.n62 LOAD_EN3_N.n61 18.0005
R397 LOAD_EN3_N.n69 LOAD_EN3_N.n68 18.0005
R398 LOAD_EN3_N.n2 LOAD_EN3_N.n1 11.6805
R399 LOAD_EN3_N.n3 LOAD_EN3_N.n2 11.6805
R400 LOAD_EN3_N.n8 LOAD_EN3_N.n7 11.6805
R401 LOAD_EN3_N.n9 LOAD_EN3_N.n8 11.6805
R402 LOAD_EN3_N.n15 LOAD_EN3_N.n14 11.6805
R403 LOAD_EN3_N.n16 LOAD_EN3_N.n15 11.6805
R404 LOAD_EN3_N.n22 LOAD_EN3_N.n21 11.6805
R405 LOAD_EN3_N.n23 LOAD_EN3_N.n22 11.6805
R406 LOAD_EN3_N.n36 LOAD_EN3_N.n35 11.6805
R407 LOAD_EN3_N.n35 LOAD_EN3_N.n34 11.6805
R408 LOAD_EN3_N.n45 LOAD_EN3_N.n44 11.6805
R409 LOAD_EN3_N.n46 LOAD_EN3_N.n45 11.6805
R410 LOAD_EN3_N.n51 LOAD_EN3_N.n50 11.6805
R411 LOAD_EN3_N.n52 LOAD_EN3_N.n51 11.6805
R412 LOAD_EN3_N.n58 LOAD_EN3_N.n57 11.6805
R413 LOAD_EN3_N.n59 LOAD_EN3_N.n58 11.6805
R414 LOAD_EN3_N.n65 LOAD_EN3_N.n64 11.6805
R415 LOAD_EN3_N.n66 LOAD_EN3_N.n65 11.6805
R416 LOAD_EN3_N.n78 LOAD_EN3_N.n77 11.6805
R417 LOAD_EN3_N.n77 LOAD_EN3_N.n76 11.6805
R418 LOAD_EN3_N.n5 LOAD_EN3_N.n0 7.16371
R419 LOAD_EN3_N.n5 LOAD_EN3_N.n4 7.16371
R420 LOAD_EN3_N.n11 LOAD_EN3_N.n6 7.16371
R421 LOAD_EN3_N.n11 LOAD_EN3_N.n10 7.16371
R422 LOAD_EN3_N.n18 LOAD_EN3_N.n13 7.16371
R423 LOAD_EN3_N.n18 LOAD_EN3_N.n17 7.16371
R424 LOAD_EN3_N.n25 LOAD_EN3_N.n20 7.16371
R425 LOAD_EN3_N.n25 LOAD_EN3_N.n24 7.16371
R426 LOAD_EN3_N.n48 LOAD_EN3_N.n43 7.16371
R427 LOAD_EN3_N.n48 LOAD_EN3_N.n47 7.16371
R428 LOAD_EN3_N.n54 LOAD_EN3_N.n49 7.16371
R429 LOAD_EN3_N.n54 LOAD_EN3_N.n53 7.16371
R430 LOAD_EN3_N.n61 LOAD_EN3_N.n56 7.16371
R431 LOAD_EN3_N.n61 LOAD_EN3_N.n60 7.16371
R432 LOAD_EN3_N.n68 LOAD_EN3_N.n63 7.16371
R433 LOAD_EN3_N.n68 LOAD_EN3_N.n67 7.16371
R434 LOAD_EN3_N.n38 LOAD_EN3_N.n37 7.12887
R435 LOAD_EN3_N.n33 LOAD_EN3_N.n32 7.12887
R436 LOAD_EN3_N.n80 LOAD_EN3_N.n79 7.12887
R437 LOAD_EN3_N.n75 LOAD_EN3_N.n74 7.12887
R438 LOAD_EN3_N.n42 LOAD_EN3_N.n41 4.5005
R439 LOAD_EN3_N.n28 LOAD_EN3_N.n27 4.5005
R440 LOAD_EN3_N.n41 LOAD_EN3_N.n40 4.5005
R441 LOAD_EN3_N.n29 LOAD_EN3_N.n28 4.5005
R442 LOAD_EN3_N.n40 LOAD_EN3_N.n39 4.5005
R443 LOAD_EN3_N.n30 LOAD_EN3_N.n29 4.5005
R444 LOAD_EN3_N.n39 LOAD_EN3_N.n38 4.5005
R445 LOAD_EN3_N.n32 LOAD_EN3_N.n30 4.5005
R446 LOAD_EN3_N.n83 LOAD_EN3_N.n70 4.5005
R447 LOAD_EN3_N.n85 LOAD_EN3_N.n84 4.5005
R448 LOAD_EN3_N.n83 LOAD_EN3_N.n82 4.5005
R449 LOAD_EN3_N.n84 LOAD_EN3_N.n71 4.5005
R450 LOAD_EN3_N.n82 LOAD_EN3_N.n81 4.5005
R451 LOAD_EN3_N.n72 LOAD_EN3_N.n71 4.5005
R452 LOAD_EN3_N.n81 LOAD_EN3_N.n80 4.5005
R453 LOAD_EN3_N.n74 LOAD_EN3_N.n72 4.5005
R454 LOAD_EN3_N.n1 LOAD_EN3_N.n0 4.42851
R455 LOAD_EN3_N.n4 LOAD_EN3_N.n3 4.42851
R456 LOAD_EN3_N.n7 LOAD_EN3_N.n6 4.42851
R457 LOAD_EN3_N.n10 LOAD_EN3_N.n9 4.42851
R458 LOAD_EN3_N.n14 LOAD_EN3_N.n13 4.42851
R459 LOAD_EN3_N.n17 LOAD_EN3_N.n16 4.42851
R460 LOAD_EN3_N.n21 LOAD_EN3_N.n20 4.42851
R461 LOAD_EN3_N.n24 LOAD_EN3_N.n23 4.42851
R462 LOAD_EN3_N.n37 LOAD_EN3_N.n36 4.42851
R463 LOAD_EN3_N.n34 LOAD_EN3_N.n33 4.42851
R464 LOAD_EN3_N.n44 LOAD_EN3_N.n43 4.42851
R465 LOAD_EN3_N.n47 LOAD_EN3_N.n46 4.42851
R466 LOAD_EN3_N.n50 LOAD_EN3_N.n49 4.42851
R467 LOAD_EN3_N.n53 LOAD_EN3_N.n52 4.42851
R468 LOAD_EN3_N.n57 LOAD_EN3_N.n56 4.42851
R469 LOAD_EN3_N.n60 LOAD_EN3_N.n59 4.42851
R470 LOAD_EN3_N.n64 LOAD_EN3_N.n63 4.42851
R471 LOAD_EN3_N.n67 LOAD_EN3_N.n66 4.42851
R472 LOAD_EN3_N.n79 LOAD_EN3_N.n78 4.42851
R473 LOAD_EN3_N.n76 LOAD_EN3_N.n75 4.42851
R474 LOAD_EN3_N LOAD_EN3_N.n42 2.86343
R475 LOAD_EN3_N.n26 LOAD_EN3_N.n19 0.362786
R476 LOAD_EN3_N.n19 LOAD_EN3_N.n12 0.362786
R477 LOAD_EN3_N.n69 LOAD_EN3_N.n62 0.362786
R478 LOAD_EN3_N.n62 LOAD_EN3_N.n55 0.362786
R479 LOAD_EN3_N.n27 LOAD_EN3_N.n26 0.344571
R480 LOAD_EN3_N.n70 LOAD_EN3_N.n69 0.344571
R481 LOAD_EN3_N LOAD_EN3_N.n85 0.297714
R482 LOAD_EN3_N.n41 LOAD_EN3_N.n28 0.0725
R483 LOAD_EN3_N.n40 LOAD_EN3_N.n29 0.0725
R484 LOAD_EN3_N.n39 LOAD_EN3_N.n30 0.0725
R485 LOAD_EN3_N.n84 LOAD_EN3_N.n83 0.0725
R486 LOAD_EN3_N.n82 LOAD_EN3_N.n71 0.0725
R487 LOAD_EN3_N.n81 LOAD_EN3_N.n72 0.0725
R488 LOAD_EN3_N.n38 LOAD_EN3_N.n31 0.0485
R489 LOAD_EN3_N.n32 LOAD_EN3_N.n31 0.0485
R490 LOAD_EN3_N.n80 LOAD_EN3_N.n73 0.0485
R491 LOAD_EN3_N.n74 LOAD_EN3_N.n73 0.0485
R492 LOAD_EN3_N.n42 LOAD_EN3_N.n27 0.0325
R493 LOAD_EN3_N.n85 LOAD_EN3_N.n70 0.0325
R494 VDD.n91 VDD.t111 102.249
R495 VDD.t109 VDD.n93 102.249
R496 VDD.t98 VDD.n21 85.2285
R497 VDD.n128 VDD.t14 85.2285
R498 VDD.t58 VDD.n59 76.5962
R499 VDD.n113 VDD.t12 76.5962
R500 VDD.n79 VDD.t119 68.0856
R501 VDD.n79 VDD.t121 68.0856
R502 VDD.t139 VDD.n78 68.0856
R503 VDD.n78 VDD.t144 68.0856
R504 VDD.n60 VDD.t160 68.0856
R505 VDD.n60 VDD.t0 68.0856
R506 VDD.n41 VDD.t68 68.0856
R507 VDD.n41 VDD.t70 68.0856
R508 VDD.t72 VDD.n40 68.0856
R509 VDD.n40 VDD.t80 68.0856
R510 VDD.n22 VDD.t88 68.0856
R511 VDD.n22 VDD.t90 68.0856
R512 VDD.t20 VDD.n124 68.0856
R513 VDD.n124 VDD.t10 68.0856
R514 VDD.t26 VDD.n123 68.0856
R515 VDD.n123 VDD.t8 68.0856
R516 VDD.t34 VDD.n114 68.0856
R517 VDD.n114 VDD.t36 68.0856
R518 VDD.t50 VDD.n104 68.0856
R519 VDD.n104 VDD.t146 68.0856
R520 VDD.t152 VDD.n103 68.0856
R521 VDD.n103 VDD.t125 68.0856
R522 VDD.t131 VDD.n94 68.0856
R523 VDD.n94 VDD.t103 68.0856
R524 VDD.n59 VDD.t60 59.575
R525 VDD.t42 VDD.n113 59.575
R526 VDD.t115 VDD.t111 34.0431
R527 VDD.t117 VDD.t115 34.0431
R528 VDD.t113 VDD.t117 34.0431
R529 VDD.t119 VDD.t113 34.0431
R530 VDD.t121 VDD.t133 34.0431
R531 VDD.t133 VDD.t135 34.0431
R532 VDD.t135 VDD.t137 34.0431
R533 VDD.t137 VDD.t139 34.0431
R534 VDD.t156 VDD.t144 34.0431
R535 VDD.t158 VDD.t156 34.0431
R536 VDD.t154 VDD.t158 34.0431
R537 VDD.t160 VDD.t154 34.0431
R538 VDD.t0 VDD.t52 34.0431
R539 VDD.t52 VDD.t54 34.0431
R540 VDD.t54 VDD.t56 34.0431
R541 VDD.t56 VDD.t58 34.0431
R542 VDD.t64 VDD.t60 34.0431
R543 VDD.t66 VDD.t64 34.0431
R544 VDD.t62 VDD.t66 34.0431
R545 VDD.t68 VDD.t62 34.0431
R546 VDD.t70 VDD.t76 34.0431
R547 VDD.t76 VDD.t78 34.0431
R548 VDD.t78 VDD.t74 34.0431
R549 VDD.t74 VDD.t72 34.0431
R550 VDD.t84 VDD.t80 34.0431
R551 VDD.t86 VDD.t84 34.0431
R552 VDD.t82 VDD.t86 34.0431
R553 VDD.t88 VDD.t82 34.0431
R554 VDD.t90 VDD.t94 34.0431
R555 VDD.t94 VDD.t96 34.0431
R556 VDD.t96 VDD.t92 34.0431
R557 VDD.t92 VDD.t98 34.0431
R558 VDD.t14 VDD.t4 34.0431
R559 VDD.t4 VDD.t16 34.0431
R560 VDD.t16 VDD.t18 34.0431
R561 VDD.t18 VDD.t20 34.0431
R562 VDD.t10 VDD.t6 34.0431
R563 VDD.t6 VDD.t22 34.0431
R564 VDD.t22 VDD.t24 34.0431
R565 VDD.t24 VDD.t26 34.0431
R566 VDD.t8 VDD.t28 34.0431
R567 VDD.t28 VDD.t30 34.0431
R568 VDD.t30 VDD.t32 34.0431
R569 VDD.t32 VDD.t34 34.0431
R570 VDD.t36 VDD.t2 34.0431
R571 VDD.t2 VDD.t38 34.0431
R572 VDD.t38 VDD.t40 34.0431
R573 VDD.t40 VDD.t42 34.0431
R574 VDD.t12 VDD.t44 34.0431
R575 VDD.t44 VDD.t46 34.0431
R576 VDD.t46 VDD.t48 34.0431
R577 VDD.t48 VDD.t50 34.0431
R578 VDD.t146 VDD.t142 34.0431
R579 VDD.t142 VDD.t148 34.0431
R580 VDD.t148 VDD.t150 34.0431
R581 VDD.t150 VDD.t152 34.0431
R582 VDD.t125 VDD.t123 34.0431
R583 VDD.t123 VDD.t127 34.0431
R584 VDD.t127 VDD.t129 34.0431
R585 VDD.t129 VDD.t131 34.0431
R586 VDD.t103 VDD.t101 34.0431
R587 VDD.t101 VDD.t105 34.0431
R588 VDD.t105 VDD.t107 34.0431
R589 VDD.t107 VDD.t109 34.0431
R590 VDD.n17 VDD.t141 17.5656
R591 VDD.n129 VDD.t100 17.5656
R592 VDD.n26 VDD.n22 17.1434
R593 VDD.n40 VDD.n39 17.1434
R594 VDD.n45 VDD.n41 17.1434
R595 VDD.n59 VDD.n58 17.1434
R596 VDD.n64 VDD.n60 17.1434
R597 VDD.n78 VDD.n77 17.1434
R598 VDD.n81 VDD.n79 17.1434
R599 VDD.n172 VDD.n94 17.1434
R600 VDD.n103 VDD.n102 17.1434
R601 VDD.n160 VDD.n104 17.1434
R602 VDD.n113 VDD.n112 17.1434
R603 VDD.n148 VDD.n114 17.1434
R604 VDD.n123 VDD.n122 17.1434
R605 VDD.n136 VDD.n124 17.1434
R606 VDD.n20 VDD.t99 7.7577
R607 VDD.n25 VDD.t89 7.7577
R608 VDD.n38 VDD.t73 7.7577
R609 VDD.n44 VDD.t69 7.7577
R610 VDD.n57 VDD.t59 7.7577
R611 VDD.n63 VDD.t161 7.7577
R612 VDD.n76 VDD.t140 7.7577
R613 VDD.n80 VDD.t120 7.7577
R614 VDD.n92 VDD.t110 7.7577
R615 VDD.n171 VDD.t132 7.7577
R616 VDD.n101 VDD.t153 7.7577
R617 VDD.n159 VDD.t51 7.7577
R618 VDD.n111 VDD.t43 7.7577
R619 VDD.n147 VDD.t35 7.7577
R620 VDD.n121 VDD.t27 7.7577
R621 VDD.n135 VDD.t21 7.7577
R622 VDD.n19 VDD.n18 7.6667
R623 VDD.n28 VDD.n27 7.6667
R624 VDD.n24 VDD.n23 7.6667
R625 VDD.n35 VDD.n34 7.6667
R626 VDD.n37 VDD.n36 7.6667
R627 VDD.n47 VDD.n46 7.6667
R628 VDD.n43 VDD.n42 7.6667
R629 VDD.n54 VDD.n53 7.6667
R630 VDD.n56 VDD.n55 7.6667
R631 VDD.n66 VDD.n65 7.6667
R632 VDD.n62 VDD.n61 7.6667
R633 VDD.n73 VDD.n72 7.6667
R634 VDD.n75 VDD.n74 7.6667
R635 VDD.n83 VDD.n82 7.6667
R636 VDD.n5 VDD.n4 7.6667
R637 VDD.n90 VDD.n89 7.6667
R638 VDD.n3 VDD.n2 7.6667
R639 VDD.n174 VDD.n173 7.6667
R640 VDD.n170 VDD.n169 7.6667
R641 VDD.n100 VDD.n99 7.6667
R642 VDD.n98 VDD.n97 7.6667
R643 VDD.n162 VDD.n161 7.6667
R644 VDD.n158 VDD.n157 7.6667
R645 VDD.n110 VDD.n109 7.6667
R646 VDD.n108 VDD.n107 7.6667
R647 VDD.n150 VDD.n149 7.6667
R648 VDD.n146 VDD.n145 7.6667
R649 VDD.n120 VDD.n119 7.6667
R650 VDD.n118 VDD.n117 7.6667
R651 VDD.n138 VDD.n137 7.6667
R652 VDD.n134 VDD.n133 7.6667
R653 VDD.n127 VDD.n126 7.6667
R654 VDD.n129 VDD.n128 4.7405
R655 VDD.n21 VDD.n17 4.7405
R656 VDD.n132 VDD.n131 4.5005
R657 VDD.n130 VDD.n125 4.5005
R658 VDD.n139 VDD.n116 4.5005
R659 VDD.n141 VDD.n140 4.5005
R660 VDD.n142 VDD.n115 4.5005
R661 VDD.n144 VDD.n143 4.5005
R662 VDD.n151 VDD.n106 4.5005
R663 VDD.n153 VDD.n152 4.5005
R664 VDD.n154 VDD.n105 4.5005
R665 VDD.n156 VDD.n155 4.5005
R666 VDD.n163 VDD.n96 4.5005
R667 VDD.n165 VDD.n164 4.5005
R668 VDD.n166 VDD.n95 4.5005
R669 VDD.n168 VDD.n167 4.5005
R670 VDD.n175 VDD.n1 4.5005
R671 VDD.n177 VDD.n176 4.5005
R672 VDD.n88 VDD.n0 4.5005
R673 VDD.n87 VDD.n86 4.5005
R674 VDD.n85 VDD.n84 4.5005
R675 VDD.n7 VDD.n6 4.5005
R676 VDD.n71 VDD.n70 4.5005
R677 VDD.n69 VDD.n8 4.5005
R678 VDD.n68 VDD.n67 4.5005
R679 VDD.n10 VDD.n9 4.5005
R680 VDD.n52 VDD.n51 4.5005
R681 VDD.n50 VDD.n11 4.5005
R682 VDD.n49 VDD.n48 4.5005
R683 VDD.n13 VDD.n12 4.5005
R684 VDD.n33 VDD.n32 4.5005
R685 VDD.n31 VDD.n14 4.5005
R686 VDD.n30 VDD.n29 4.5005
R687 VDD.n16 VDD.n15 4.5005
R688 VDD.n93 VDD.n91 0.7805
R689 VDD VDD.n0 0.7115
R690 VDD VDD.n177 0.5615
R691 VDD.n131 VDD.n116 0.4325
R692 VDD.n142 VDD.n141 0.4325
R693 VDD.n143 VDD.n106 0.4325
R694 VDD.n154 VDD.n153 0.4325
R695 VDD.n155 VDD.n96 0.4325
R696 VDD.n166 VDD.n165 0.4325
R697 VDD.n167 VDD.n1 0.4325
R698 VDD.n86 VDD.n85 0.4325
R699 VDD.n70 VDD.n6 0.4325
R700 VDD.n69 VDD.n68 0.4325
R701 VDD.n51 VDD.n9 0.4325
R702 VDD.n50 VDD.n49 0.4325
R703 VDD.n32 VDD.n12 0.4325
R704 VDD.n31 VDD.n30 0.4325
R705 VDD.n130 VDD.n129 0.404
R706 VDD.n17 VDD.n15 0.404
R707 VDD.n91 VDD.n90 0.1805
R708 VDD.n112 VDD.n110 0.1655
R709 VDD.n128 VDD.n127 0.1505
R710 VDD.n138 VDD.n136 0.1505
R711 VDD.n122 VDD.n120 0.1505
R712 VDD.n150 VDD.n148 0.1505
R713 VDD.n162 VDD.n160 0.1505
R714 VDD.n102 VDD.n100 0.1505
R715 VDD.n174 VDD.n172 0.1505
R716 VDD.n83 VDD.n81 0.1505
R717 VDD.n77 VDD.n73 0.1505
R718 VDD.n66 VDD.n64 0.1505
R719 VDD.n47 VDD.n45 0.1505
R720 VDD.n39 VDD.n35 0.1505
R721 VDD.n28 VDD.n26 0.1505
R722 VDD.n58 VDD.n54 0.1355
R723 VDD.n135 VDD.n134 0.1205
R724 VDD.n121 VDD.n118 0.1205
R725 VDD.n147 VDD.n146 0.1205
R726 VDD.n111 VDD.n108 0.1205
R727 VDD.n159 VDD.n158 0.1205
R728 VDD.n101 VDD.n98 0.1205
R729 VDD.n171 VDD.n170 0.1205
R730 VDD.n92 VDD.n3 0.1205
R731 VDD.n93 VDD.n92 0.1205
R732 VDD.n80 VDD.n5 0.1205
R733 VDD.n76 VDD.n75 0.1205
R734 VDD.n63 VDD.n62 0.1205
R735 VDD.n57 VDD.n56 0.1205
R736 VDD.n44 VDD.n43 0.1205
R737 VDD.n38 VDD.n37 0.1205
R738 VDD.n25 VDD.n24 0.1205
R739 VDD.n20 VDD.n19 0.1205
R740 VDD.n58 VDD.n57 0.1055
R741 VDD.n18 VDD.t97 0.0915
R742 VDD.n18 VDD.t93 0.0915
R743 VDD.n27 VDD.t91 0.0915
R744 VDD.n27 VDD.t95 0.0915
R745 VDD.n23 VDD.t87 0.0915
R746 VDD.n23 VDD.t83 0.0915
R747 VDD.n34 VDD.t81 0.0915
R748 VDD.n34 VDD.t85 0.0915
R749 VDD.n36 VDD.t79 0.0915
R750 VDD.n36 VDD.t75 0.0915
R751 VDD.n46 VDD.t71 0.0915
R752 VDD.n46 VDD.t77 0.0915
R753 VDD.n42 VDD.t67 0.0915
R754 VDD.n42 VDD.t63 0.0915
R755 VDD.n53 VDD.t61 0.0915
R756 VDD.n53 VDD.t65 0.0915
R757 VDD.n55 VDD.t55 0.0915
R758 VDD.n55 VDD.t57 0.0915
R759 VDD.n65 VDD.t1 0.0915
R760 VDD.n65 VDD.t53 0.0915
R761 VDD.n61 VDD.t159 0.0915
R762 VDD.n61 VDD.t155 0.0915
R763 VDD.n72 VDD.t145 0.0915
R764 VDD.n72 VDD.t157 0.0915
R765 VDD.n74 VDD.t136 0.0915
R766 VDD.n74 VDD.t138 0.0915
R767 VDD.n82 VDD.t122 0.0915
R768 VDD.n82 VDD.t134 0.0915
R769 VDD.n4 VDD.t118 0.0915
R770 VDD.n4 VDD.t114 0.0915
R771 VDD.n89 VDD.t112 0.0915
R772 VDD.n89 VDD.t116 0.0915
R773 VDD.n2 VDD.t106 0.0915
R774 VDD.n2 VDD.t108 0.0915
R775 VDD.n173 VDD.t104 0.0915
R776 VDD.n173 VDD.t102 0.0915
R777 VDD.n169 VDD.t128 0.0915
R778 VDD.n169 VDD.t130 0.0915
R779 VDD.n99 VDD.t126 0.0915
R780 VDD.n99 VDD.t124 0.0915
R781 VDD.n97 VDD.t149 0.0915
R782 VDD.n97 VDD.t151 0.0915
R783 VDD.n161 VDD.t147 0.0915
R784 VDD.n161 VDD.t143 0.0915
R785 VDD.n157 VDD.t47 0.0915
R786 VDD.n157 VDD.t49 0.0915
R787 VDD.n109 VDD.t13 0.0915
R788 VDD.n109 VDD.t45 0.0915
R789 VDD.n107 VDD.t39 0.0915
R790 VDD.n107 VDD.t41 0.0915
R791 VDD.n149 VDD.t37 0.0915
R792 VDD.n149 VDD.t3 0.0915
R793 VDD.n145 VDD.t31 0.0915
R794 VDD.n145 VDD.t33 0.0915
R795 VDD.n119 VDD.t9 0.0915
R796 VDD.n119 VDD.t29 0.0915
R797 VDD.n117 VDD.t23 0.0915
R798 VDD.n117 VDD.t25 0.0915
R799 VDD.n137 VDD.t11 0.0915
R800 VDD.n137 VDD.t7 0.0915
R801 VDD.n133 VDD.t17 0.0915
R802 VDD.n133 VDD.t19 0.0915
R803 VDD.n126 VDD.t15 0.0915
R804 VDD.n126 VDD.t5 0.0915
R805 VDD.n136 VDD.n135 0.0905
R806 VDD.n122 VDD.n121 0.0905
R807 VDD.n148 VDD.n147 0.0905
R808 VDD.n160 VDD.n159 0.0905
R809 VDD.n102 VDD.n101 0.0905
R810 VDD.n172 VDD.n171 0.0905
R811 VDD.n81 VDD.n80 0.0905
R812 VDD.n77 VDD.n76 0.0905
R813 VDD.n64 VDD.n63 0.0905
R814 VDD.n45 VDD.n44 0.0905
R815 VDD.n39 VDD.n38 0.0905
R816 VDD.n26 VDD.n25 0.0905
R817 VDD.n21 VDD.n20 0.0905
R818 VDD.n112 VDD.n111 0.0755
R819 VDD.n127 VDD.n125 0.0665
R820 VDD.n139 VDD.n138 0.0665
R821 VDD.n120 VDD.n115 0.0665
R822 VDD.n151 VDD.n150 0.0665
R823 VDD.n110 VDD.n105 0.0665
R824 VDD.n163 VDD.n162 0.0665
R825 VDD.n100 VDD.n95 0.0665
R826 VDD.n175 VDD.n174 0.0665
R827 VDD.n90 VDD.n88 0.0665
R828 VDD.n84 VDD.n83 0.0665
R829 VDD.n73 VDD.n71 0.0665
R830 VDD.n67 VDD.n66 0.0665
R831 VDD.n54 VDD.n52 0.0665
R832 VDD.n48 VDD.n47 0.0665
R833 VDD.n35 VDD.n33 0.0665
R834 VDD.n29 VDD.n28 0.0665
R835 VDD.n131 VDD.n130 0.0485
R836 VDD.n141 VDD.n116 0.0485
R837 VDD.n143 VDD.n142 0.0485
R838 VDD.n153 VDD.n106 0.0485
R839 VDD.n155 VDD.n154 0.0485
R840 VDD.n165 VDD.n96 0.0485
R841 VDD.n167 VDD.n166 0.0485
R842 VDD.n177 VDD.n1 0.0485
R843 VDD.n86 VDD.n0 0.0485
R844 VDD.n85 VDD.n6 0.0485
R845 VDD.n70 VDD.n69 0.0485
R846 VDD.n68 VDD.n9 0.0485
R847 VDD.n51 VDD.n50 0.0485
R848 VDD.n49 VDD.n12 0.0485
R849 VDD.n32 VDD.n31 0.0485
R850 VDD.n30 VDD.n15 0.0485
R851 VDD.n132 VDD.n125 0.0485
R852 VDD.n140 VDD.n139 0.0485
R853 VDD.n144 VDD.n115 0.0485
R854 VDD.n152 VDD.n151 0.0485
R855 VDD.n156 VDD.n105 0.0485
R856 VDD.n164 VDD.n163 0.0485
R857 VDD.n168 VDD.n95 0.0485
R858 VDD.n176 VDD.n175 0.0485
R859 VDD.n88 VDD.n87 0.0485
R860 VDD.n84 VDD.n7 0.0485
R861 VDD.n71 VDD.n8 0.0485
R862 VDD.n67 VDD.n10 0.0485
R863 VDD.n52 VDD.n11 0.0485
R864 VDD.n48 VDD.n13 0.0485
R865 VDD.n33 VDD.n14 0.0485
R866 VDD.n29 VDD.n16 0.0485
R867 VDD.n134 VDD.n132 0.0065
R868 VDD.n140 VDD.n118 0.0065
R869 VDD.n146 VDD.n144 0.0065
R870 VDD.n152 VDD.n108 0.0065
R871 VDD.n158 VDD.n156 0.0065
R872 VDD.n164 VDD.n98 0.0065
R873 VDD.n170 VDD.n168 0.0065
R874 VDD.n176 VDD.n3 0.0065
R875 VDD.n87 VDD.n5 0.0065
R876 VDD.n75 VDD.n7 0.0065
R877 VDD.n62 VDD.n8 0.0065
R878 VDD.n56 VDD.n10 0.0065
R879 VDD.n43 VDD.n11 0.0065
R880 VDD.n37 VDD.n13 0.0065
R881 VDD.n24 VDD.n14 0.0065
R882 VDD.n19 VDD.n16 0.0065
R883 VSS.n102 VSS.t14 158.066
R884 VSS.n20 VSS.t25 158.066
R885 VSS.n103 VSS.n102 136.996
R886 VSS.n104 VSS.n103 136.996
R887 VSS.n105 VSS.n104 136.996
R888 VSS.n106 VSS.n105 136.996
R889 VSS.n24 VSS.n23 136.996
R890 VSS.n23 VSS.n22 136.996
R891 VSS.n22 VSS.n21 136.996
R892 VSS.n21 VSS.n20 136.996
R893 VSS.n107 VSS.n106 134.881
R894 VSS.n25 VSS.n24 134.881
R895 VSS.t26 VSS.n157 117.553
R896 VSS.n73 VSS.t65 117.553
R897 VSS.n156 VSS.n99 50.7505
R898 VSS.n74 VSS.n15 50.7505
R899 VSS.n160 VSS.t30 48.4048
R900 VSS.n79 VSS.t61 48.4048
R901 VSS.t15 VSS.n98 44.2558
R902 VSS.t19 VSS.n16 44.2558
R903 VSS.n64 VSS.n17 42.0005
R904 VSS.n124 VSS.n97 42.0005
R905 VSS.n35 VSS.n19 35.0005
R906 VSS.n37 VSS.n28 35.0005
R907 VSS.n40 VSS.n28 35.0005
R908 VSS.n44 VSS.n43 35.0005
R909 VSS.n46 VSS.n32 35.0005
R910 VSS.n49 VSS.n32 35.0005
R911 VSS.n51 VSS.n26 35.0005
R912 VSS.n54 VSS.n26 35.0005
R913 VSS.n56 VSS.n34 35.0005
R914 VSS.n60 VSS.n15 35.0005
R915 VSS.n120 VSS.n97 35.0005
R916 VSS.n120 VSS.n95 35.0005
R917 VSS.n95 VSS.n6 35.0005
R918 VSS.n167 VSS.n6 35.0005
R919 VSS.n167 VSS.n4 35.0005
R920 VSS.n84 VSS.n4 35.0005
R921 VSS.n84 VSS.n83 35.0005
R922 VSS.n83 VSS.n11 35.0005
R923 VSS.n69 VSS.n11 35.0005
R924 VSS.n69 VSS.n17 35.0005
R925 VSS.n128 VSS.n118 35.0005
R926 VSS.n131 VSS.n130 35.0005
R927 VSS.n135 VSS.n115 35.0005
R928 VSS.n138 VSS.n137 35.0005
R929 VSS.n142 VSS.n112 35.0005
R930 VSS.n145 VSS.n144 35.0005
R931 VSS.n149 VSS.n109 35.0005
R932 VSS.n152 VSS.n151 35.0005
R933 VSS.n156 VSS.n91 35.0005
R934 VSS.n161 VSS.n91 35.0005
R935 VSS.n161 VSS.n8 35.0005
R936 VSS.n165 VSS.n8 35.0005
R937 VSS.n165 VSS.n7 35.0005
R938 VSS.n87 VSS.n7 35.0005
R939 VSS.n87 VSS.n10 35.0005
R940 VSS.n78 VSS.n10 35.0005
R941 VSS.n78 VSS.n13 35.0005
R942 VSS.n74 VSS.n13 35.0005
R943 VSS.n108 VSS.t15 34.575
R944 VSS.n62 VSS.t19 34.575
R945 VSS.n93 VSS.t6 31.809
R946 VSS.n81 VSS.t4 31.809
R947 VSS.t28 VSS.t29 27.6601
R948 VSS.t71 VSS.t72 27.6601
R949 VSS.t74 VSS.t73 27.6601
R950 VSS.t6 VSS.t7 27.6601
R951 VSS.t39 VSS.t37 27.6601
R952 VSS.t41 VSS.t39 27.6601
R953 VSS.t45 VSS.t41 27.6601
R954 VSS.t49 VSS.t47 27.6601
R955 VSS.t43 VSS.t49 27.6601
R956 VSS.t51 VSS.t43 27.6601
R957 VSS.t4 VSS.t3 27.6601
R958 VSS.t68 VSS.t67 27.6601
R959 VSS.t69 VSS.t70 27.6601
R960 VSS.t62 VSS.t63 27.6601
R961 VSS.t72 VSS.n94 24.8941
R962 VSS.n80 VSS.t69 24.8941
R963 VSS.n102 VSS.t59 21.0713
R964 VSS.n103 VSS.t22 21.0713
R965 VSS.n104 VSS.t12 21.0713
R966 VSS.n105 VSS.t18 21.0713
R967 VSS.n106 VSS.t16 21.0713
R968 VSS.n24 VSS.t17 21.0713
R969 VSS.n23 VSS.t13 21.0713
R970 VSS.n22 VSS.t11 21.0713
R971 VSS.n21 VSS.t5 21.0713
R972 VSS.n20 VSS.t60 21.0713
R973 VSS.t27 VSS.t20 20.7452
R974 VSS.t7 VSS.t31 20.7452
R975 VSS.t8 VSS.t35 20.7452
R976 VSS.t37 VSS.t10 20.7452
R977 VSS.t0 VSS.t51 20.7452
R978 VSS.t2 VSS.t55 20.7452
R979 VSS.t3 VSS.t57 20.7452
R980 VSS.t21 VSS.t64 20.7452
R981 VSS.t30 VSS.n159 17.9792
R982 VSS.n71 VSS.t61 17.9792
R983 VSS.n158 VSS.n96 16.5962
R984 VSS.n93 VSS.n92 16.5962
R985 VSS.n82 VSS.n81 16.5962
R986 VSS.n72 VSS.n70 16.5962
R987 VSS.n160 VSS.t71 13.8303
R988 VSS.t23 VSS.t74 13.8303
R989 VSS.t75 VSS.t23 13.8303
R990 VSS.n92 VSS.t75 13.8303
R991 VSS.n166 VSS.t33 13.8303
R992 VSS.n85 VSS.t45 13.8303
R993 VSS.t47 VSS.n85 13.8303
R994 VSS.n86 VSS.t53 13.8303
R995 VSS.n82 VSS.t66 13.8303
R996 VSS.t24 VSS.t66 13.8303
R997 VSS.t67 VSS.t24 13.8303
R998 VSS.t70 VSS.n79 13.8303
R999 VSS.n157 VSS.n98 11.0643
R1000 VSS.n73 VSS.n16 11.0643
R1001 VSS.n108 VSS.n107 9.68135
R1002 VSS.n159 VSS.t29 9.68135
R1003 VSS.n71 VSS.t62 9.68135
R1004 VSS.n62 VSS.n25 9.68135
R1005 VSS.n171 VSS.n170 7.69289
R1006 VSS.n173 VSS.n172 7.69289
R1007 VSS.n175 VSS.n174 7.69289
R1008 VSS.n177 VSS.n176 7.69289
R1009 VSS.n181 VSS.n178 7.69289
R1010 VSS.n180 VSS.n179 7.69289
R1011 VSS.n2 VSS.n1 7.69289
R1012 VSS.n96 VSS.t27 6.91539
R1013 VSS.t20 VSS.t28 6.91539
R1014 VSS.t31 VSS.t8 6.91539
R1015 VSS.t35 VSS.t9 6.91539
R1016 VSS.n166 VSS.t9 6.91539
R1017 VSS.t10 VSS.t33 6.91539
R1018 VSS.t53 VSS.t0 6.91539
R1019 VSS.n86 VSS.t1 6.91539
R1020 VSS.t55 VSS.t1 6.91539
R1021 VSS.t57 VSS.t2 6.91539
R1022 VSS.t63 VSS.t21 6.91539
R1023 VSS.t64 VSS.n70 6.91539
R1024 VSS.n73 VSS.n17 5.2005
R1025 VSS.n66 VSS.n17 5.2005
R1026 VSS.n70 VSS.n69 5.2005
R1027 VSS.n69 VSS.n68 5.2005
R1028 VSS.n79 VSS.n11 5.2005
R1029 VSS.n67 VSS.n11 5.2005
R1030 VSS.n83 VSS.n82 5.2005
R1031 VSS.n83 VSS.n12 5.2005
R1032 VSS.n86 VSS.n84 5.2005
R1033 VSS.n84 VSS.n3 5.2005
R1034 VSS.n85 VSS.n4 5.2005
R1035 VSS.n169 VSS.n4 5.2005
R1036 VSS.n167 VSS.n166 5.2005
R1037 VSS.n168 VSS.n167 5.2005
R1038 VSS.n92 VSS.n6 5.2005
R1039 VSS.n6 VSS.n5 5.2005
R1040 VSS.n160 VSS.n95 5.2005
R1041 VSS.n119 VSS.n95 5.2005
R1042 VSS.n120 VSS.n96 5.2005
R1043 VSS.n121 VSS.n120 5.2005
R1044 VSS.n157 VSS.n97 5.2005
R1045 VSS.n122 VSS.n97 5.2005
R1046 VSS.n154 VSS.n99 5.2005
R1047 VSS.n153 VSS.n152 5.2005
R1048 VSS.n151 VSS.n100 5.2005
R1049 VSS.n149 VSS.n148 5.2005
R1050 VSS.n147 VSS.n109 5.2005
R1051 VSS.n146 VSS.n145 5.2005
R1052 VSS.n144 VSS.n110 5.2005
R1053 VSS.n142 VSS.n141 5.2005
R1054 VSS.n140 VSS.n112 5.2005
R1055 VSS.n139 VSS.n138 5.2005
R1056 VSS.n137 VSS.n113 5.2005
R1057 VSS.n135 VSS.n134 5.2005
R1058 VSS.n133 VSS.n115 5.2005
R1059 VSS.n132 VSS.n131 5.2005
R1060 VSS.n130 VSS.n116 5.2005
R1061 VSS.n128 VSS.n127 5.2005
R1062 VSS.n126 VSS.n118 5.2005
R1063 VSS.n125 VSS.n124 5.2005
R1064 VSS.n74 VSS.n73 5.2005
R1065 VSS.n75 VSS.n74 5.2005
R1066 VSS.n70 VSS.n13 5.2005
R1067 VSS.n76 VSS.n13 5.2005
R1068 VSS.n79 VSS.n78 5.2005
R1069 VSS.n78 VSS.n77 5.2005
R1070 VSS.n82 VSS.n10 5.2005
R1071 VSS.n10 VSS.n9 5.2005
R1072 VSS.n87 VSS.n86 5.2005
R1073 VSS.n88 VSS.n87 5.2005
R1074 VSS.n85 VSS.n7 5.2005
R1075 VSS.n89 VSS.n7 5.2005
R1076 VSS.n166 VSS.n165 5.2005
R1077 VSS.n165 VSS.n164 5.2005
R1078 VSS.n92 VSS.n8 5.2005
R1079 VSS.n163 VSS.n8 5.2005
R1080 VSS.n161 VSS.n160 5.2005
R1081 VSS.n162 VSS.n161 5.2005
R1082 VSS.n96 VSS.n91 5.2005
R1083 VSS.n91 VSS.n90 5.2005
R1084 VSS.n157 VSS.n156 5.2005
R1085 VSS.n156 VSS.n155 5.2005
R1086 VSS.n65 VSS.n64 5.2005
R1087 VSS.n19 VSS.n18 5.2005
R1088 VSS.n36 VSS.n35 5.2005
R1089 VSS.n38 VSS.n37 5.2005
R1090 VSS.n62 VSS.n28 5.2005
R1091 VSS.n39 VSS.n28 5.2005
R1092 VSS.n41 VSS.n40 5.2005
R1093 VSS.n43 VSS.n42 5.2005
R1094 VSS.n45 VSS.n44 5.2005
R1095 VSS.n47 VSS.n46 5.2005
R1096 VSS.n62 VSS.n32 5.2005
R1097 VSS.n48 VSS.n32 5.2005
R1098 VSS.n50 VSS.n49 5.2005
R1099 VSS.n52 VSS.n51 5.2005
R1100 VSS.n62 VSS.n26 5.2005
R1101 VSS.n53 VSS.n26 5.2005
R1102 VSS.n55 VSS.n54 5.2005
R1103 VSS.n57 VSS.n56 5.2005
R1104 VSS.n58 VSS.n34 5.2005
R1105 VSS.n60 VSS.n59 5.2005
R1106 VSS.n62 VSS.n15 5.2005
R1107 VSS.n15 VSS.n14 5.2005
R1108 VSS.n177 VSS.n169 4.8755
R1109 VSS.n182 VSS.n2 4.7405
R1110 VSS.n171 VSS.n0 4.7405
R1111 VSS.n182 VSS.n181 4.5005
R1112 VSS.n175 VSS.n0 4.5005
R1113 VSS.n25 VSS.n16 4.44204
R1114 VSS.n72 VSS.n71 4.44204
R1115 VSS.n81 VSS.n80 4.44204
R1116 VSS.n94 VSS.n93 4.44204
R1117 VSS.n159 VSS.n158 4.44204
R1118 VSS.n107 VSS.n98 4.44204
R1119 VSS.n158 VSS.t26 4.14944
R1120 VSS.t65 VSS.n72 4.14944
R1121 VSS.n101 VSS.n99 4.00981
R1122 VSS.n151 VSS.n150 4.00981
R1123 VSS.n111 VSS.n109 4.00981
R1124 VSS.n144 VSS.n143 4.00981
R1125 VSS.n114 VSS.n112 4.00981
R1126 VSS.n137 VSS.n136 4.00981
R1127 VSS.n117 VSS.n115 4.00981
R1128 VSS.n130 VSS.n129 4.00981
R1129 VSS.n123 VSS.n118 4.00981
R1130 VSS.n63 VSS.n19 4.00981
R1131 VSS.n37 VSS.n29 4.00981
R1132 VSS.n43 VSS.n30 4.00981
R1133 VSS.n46 VSS.n31 4.00981
R1134 VSS.n51 VSS.n27 4.00981
R1135 VSS.n56 VSS.n33 4.00981
R1136 VSS.n61 VSS.n60 4.00981
R1137 VSS.n64 VSS.n63 4.00981
R1138 VSS.n35 VSS.n29 4.00981
R1139 VSS.n40 VSS.n30 4.00981
R1140 VSS.n44 VSS.n31 4.00981
R1141 VSS.n49 VSS.n27 4.00981
R1142 VSS.n54 VSS.n33 4.00981
R1143 VSS.n61 VSS.n34 4.00981
R1144 VSS.n124 VSS.n123 4.00981
R1145 VSS.n129 VSS.n128 4.00981
R1146 VSS.n131 VSS.n117 4.00981
R1147 VSS.n136 VSS.n135 4.00981
R1148 VSS.n138 VSS.n114 4.00981
R1149 VSS.n143 VSS.n142 4.00981
R1150 VSS.n145 VSS.n111 4.00981
R1151 VSS.n150 VSS.n149 4.00981
R1152 VSS.n152 VSS.n101 4.00981
R1153 VSS.n94 VSS.t73 2.76646
R1154 VSS.n80 VSS.t68 2.76646
R1155 VSS.n155 VSS.n154 0.653
R1156 VSS.n75 VSS.n14 0.653
R1157 VSS.n108 VSS.n101 0.596595
R1158 VSS.n150 VSS.n108 0.596595
R1159 VSS.n111 VSS.n108 0.596595
R1160 VSS.n143 VSS.n108 0.596595
R1161 VSS.n114 VSS.n108 0.596595
R1162 VSS.n136 VSS.n108 0.596595
R1163 VSS.n117 VSS.n108 0.596595
R1164 VSS.n129 VSS.n108 0.596595
R1165 VSS.n123 VSS.n108 0.596595
R1166 VSS.n63 VSS.n62 0.596595
R1167 VSS.n62 VSS.n29 0.596595
R1168 VSS.n62 VSS.n30 0.596595
R1169 VSS.n62 VSS.n31 0.596595
R1170 VSS.n62 VSS.n27 0.596595
R1171 VSS.n62 VSS.n33 0.596595
R1172 VSS.n62 VSS.n61 0.596595
R1173 VSS.n125 VSS.n122 0.5405
R1174 VSS.n66 VSS.n65 0.5405
R1175 VSS.n122 VSS.n121 0.4505
R1176 VSS.n121 VSS.n119 0.4505
R1177 VSS.n119 VSS.n5 0.4505
R1178 VSS.n168 VSS.n5 0.4505
R1179 VSS.n169 VSS.n168 0.4505
R1180 VSS.n169 VSS.n3 0.4505
R1181 VSS.n12 VSS.n3 0.4505
R1182 VSS.n67 VSS.n12 0.4505
R1183 VSS.n68 VSS.n67 0.4505
R1184 VSS.n68 VSS.n66 0.4505
R1185 VSS.n126 VSS.n125 0.4505
R1186 VSS.n127 VSS.n126 0.4505
R1187 VSS.n127 VSS.n116 0.4505
R1188 VSS.n132 VSS.n116 0.4505
R1189 VSS.n133 VSS.n132 0.4505
R1190 VSS.n134 VSS.n133 0.4505
R1191 VSS.n134 VSS.n113 0.4505
R1192 VSS.n139 VSS.n113 0.4505
R1193 VSS.n140 VSS.n139 0.4505
R1194 VSS.n141 VSS.n140 0.4505
R1195 VSS.n141 VSS.n110 0.4505
R1196 VSS.n146 VSS.n110 0.4505
R1197 VSS.n147 VSS.n146 0.4505
R1198 VSS.n148 VSS.n147 0.4505
R1199 VSS.n148 VSS.n100 0.4505
R1200 VSS.n153 VSS.n100 0.4505
R1201 VSS.n154 VSS.n153 0.4505
R1202 VSS.n155 VSS.n90 0.4505
R1203 VSS.n162 VSS.n90 0.4505
R1204 VSS.n163 VSS.n162 0.4505
R1205 VSS.n164 VSS.n163 0.4505
R1206 VSS.n164 VSS.n89 0.4505
R1207 VSS.n89 VSS.n88 0.4505
R1208 VSS.n88 VSS.n9 0.4505
R1209 VSS.n77 VSS.n9 0.4505
R1210 VSS.n77 VSS.n76 0.4505
R1211 VSS.n76 VSS.n75 0.4505
R1212 VSS.n65 VSS.n18 0.4505
R1213 VSS.n36 VSS.n18 0.4505
R1214 VSS.n38 VSS.n36 0.4505
R1215 VSS.n39 VSS.n38 0.4505
R1216 VSS.n41 VSS.n39 0.4505
R1217 VSS.n42 VSS.n41 0.4505
R1218 VSS.n45 VSS.n42 0.4505
R1219 VSS.n47 VSS.n45 0.4505
R1220 VSS.n48 VSS.n47 0.4505
R1221 VSS.n50 VSS.n48 0.4505
R1222 VSS.n52 VSS.n50 0.4505
R1223 VSS.n53 VSS.n52 0.4505
R1224 VSS.n55 VSS.n53 0.4505
R1225 VSS.n57 VSS.n55 0.4505
R1226 VSS.n58 VSS.n57 0.4505
R1227 VSS.n59 VSS.n58 0.4505
R1228 VSS.n59 VSS.n14 0.4505
R1229 VSS VSS.n0 0.1955
R1230 VSS.n180 VSS.n2 0.1205
R1231 VSS.n181 VSS.n180 0.1205
R1232 VSS.n181 VSS.n177 0.1205
R1233 VSS.n177 VSS.n175 0.1205
R1234 VSS.n175 VSS.n173 0.1205
R1235 VSS.n173 VSS.n171 0.1205
R1236 VSS.n170 VSS.t56 0.0824
R1237 VSS.n170 VSS.t58 0.0824
R1238 VSS.n172 VSS.t52 0.0824
R1239 VSS.n172 VSS.t54 0.0824
R1240 VSS.n174 VSS.t50 0.0824
R1241 VSS.n174 VSS.t44 0.0824
R1242 VSS.n176 VSS.t46 0.0824
R1243 VSS.n176 VSS.t48 0.0824
R1244 VSS.n178 VSS.t40 0.0824
R1245 VSS.n178 VSS.t42 0.0824
R1246 VSS.n179 VSS.t34 0.0824
R1247 VSS.n179 VSS.t38 0.0824
R1248 VSS.n1 VSS.t32 0.0824
R1249 VSS.n1 VSS.t36 0.0824
R1250 VSS VSS.n182 0.0455
R1251 a_n2292_n6800.n20 a_n2292_n6800.t0 7.96426
R1252 a_n2292_n6800.n11 a_n2292_n6800.t17 7.85367
R1253 a_n2292_n6800.t13 a_n2292_n6800.n28 7.77479
R1254 a_n2292_n6800.n6 a_n2292_n6800.n5 7.77177
R1255 a_n2292_n6800.n9 a_n2292_n6800.t21 7.75914
R1256 a_n2292_n6800.n27 a_n2292_n6800.n26 7.69289
R1257 a_n2292_n6800.n25 a_n2292_n6800.n1 7.69289
R1258 a_n2292_n6800.n24 a_n2292_n6800.n23 7.69289
R1259 a_n2292_n6800.n22 a_n2292_n6800.n2 7.69289
R1260 a_n2292_n6800.n4 a_n2292_n6800.n3 7.69289
R1261 a_n2292_n6800.n20 a_n2292_n6800.n19 7.69289
R1262 a_n2292_n6800.n8 a_n2292_n6800.n7 7.67724
R1263 a_n2292_n6800.n13 a_n2292_n6800.n12 7.67724
R1264 a_n2292_n6800.n15 a_n2292_n6800.n14 7.67724
R1265 a_n2292_n6800.n28 a_n2292_n6800.n0 4.7405
R1266 a_n2292_n6800.n21 a_n2292_n6800.n20 4.7405
R1267 a_n2292_n6800.n22 a_n2292_n6800.n21 4.5005
R1268 a_n2292_n6800.n25 a_n2292_n6800.n0 4.5005
R1269 a_n2292_n6800.n16 a_n2292_n6800.n15 4.5005
R1270 a_n2292_n6800.n10 a_n2292_n6800.n9 4.5005
R1271 a_n2292_n6800.n16 a_n2292_n6800.n11 2.35421
R1272 a_n2292_n6800.n10 a_n2292_n6800.n6 2.35421
R1273 a_n2292_n6800.n17 a_n2292_n6800.n16 0.608
R1274 a_n2292_n6800.n17 a_n2292_n6800.n10 0.548
R1275 a_n2292_n6800.n18 a_n2292_n6800.n17 0.514786
R1276 a_n2292_n6800.n20 a_n2292_n6800.n4 0.189974
R1277 a_n2292_n6800.n22 a_n2292_n6800.n4 0.189974
R1278 a_n2292_n6800.n24 a_n2292_n6800.n22 0.189974
R1279 a_n2292_n6800.n25 a_n2292_n6800.n24 0.189974
R1280 a_n2292_n6800.n27 a_n2292_n6800.n25 0.189974
R1281 a_n2292_n6800.n28 a_n2292_n6800.n27 0.189974
R1282 a_n2292_n6800.n9 a_n2292_n6800.n8 0.189974
R1283 a_n2292_n6800.n15 a_n2292_n6800.n13 0.189974
R1284 a_n2292_n6800.n18 a_n2292_n6800.n0 0.128
R1285 a_n2292_n6800.n13 a_n2292_n6800.n11 0.0925875
R1286 a_n2292_n6800.n8 a_n2292_n6800.n6 0.0925875
R1287 a_n2292_n6800.n26 a_n2292_n6800.t11 0.0824
R1288 a_n2292_n6800.n26 a_n2292_n6800.t12 0.0824
R1289 a_n2292_n6800.n1 a_n2292_n6800.t9 0.0824
R1290 a_n2292_n6800.n1 a_n2292_n6800.t10 0.0824
R1291 a_n2292_n6800.n23 a_n2292_n6800.t7 0.0824
R1292 a_n2292_n6800.n23 a_n2292_n6800.t8 0.0824
R1293 a_n2292_n6800.n2 a_n2292_n6800.t5 0.0824
R1294 a_n2292_n6800.n2 a_n2292_n6800.t6 0.0824
R1295 a_n2292_n6800.n3 a_n2292_n6800.t3 0.0824
R1296 a_n2292_n6800.n3 a_n2292_n6800.t4 0.0824
R1297 a_n2292_n6800.n7 a_n2292_n6800.t22 0.0824
R1298 a_n2292_n6800.n7 a_n2292_n6800.t23 0.0824
R1299 a_n2292_n6800.n5 a_n2292_n6800.t19 0.0824
R1300 a_n2292_n6800.n5 a_n2292_n6800.t20 0.0824
R1301 a_n2292_n6800.n12 a_n2292_n6800.t15 0.0824
R1302 a_n2292_n6800.n12 a_n2292_n6800.t16 0.0824
R1303 a_n2292_n6800.n14 a_n2292_n6800.t18 0.0824
R1304 a_n2292_n6800.n14 a_n2292_n6800.t14 0.0824
R1305 a_n2292_n6800.n19 a_n2292_n6800.t1 0.0824
R1306 a_n2292_n6800.n19 a_n2292_n6800.t2 0.0824
R1307 a_n2292_n6800.n21 a_n2292_n6800.n18 0.008
R1308 a_n1292_n2000.n9 a_n1292_n2000.n4 10.495
R1309 a_n1292_n2000.n9 a_n1292_n2000.n8 10.1847
R1310 a_n1292_n2000.n10 a_n1292_n2000.n9 9.0005
R1311 a_n1292_n2000.t4 a_n1292_n2000.n12 7.96427
R1312 a_n1292_n2000.n6 a_n1292_n2000.t9 7.96427
R1313 a_n1292_n2000.n3 a_n1292_n2000.t10 7.96426
R1314 a_n1292_n2000.n4 a_n1292_n2000.n1 7.835
R1315 a_n1292_n2000.n8 a_n1292_n2000.n7 7.835
R1316 a_n1292_n2000.n10 a_n1292_n2000.n0 7.835
R1317 a_n1292_n2000.n3 a_n1292_n2000.n2 7.69289
R1318 a_n1292_n2000.n6 a_n1292_n2000.n5 7.69289
R1319 a_n1292_n2000.n12 a_n1292_n2000.n11 7.69289
R1320 a_n1292_n2000.n1 a_n1292_n2000.t13 0.0824
R1321 a_n1292_n2000.n1 a_n1292_n2000.t14 0.0824
R1322 a_n1292_n2000.n2 a_n1292_n2000.t11 0.0824
R1323 a_n1292_n2000.n2 a_n1292_n2000.t12 0.0824
R1324 a_n1292_n2000.n5 a_n1292_n2000.t7 0.0824
R1325 a_n1292_n2000.n5 a_n1292_n2000.t8 0.0824
R1326 a_n1292_n2000.n7 a_n1292_n2000.t5 0.0824
R1327 a_n1292_n2000.n7 a_n1292_n2000.t6 0.0824
R1328 a_n1292_n2000.n11 a_n1292_n2000.t2 0.0824
R1329 a_n1292_n2000.n11 a_n1292_n2000.t3 0.0824
R1330 a_n1292_n2000.n0 a_n1292_n2000.t0 0.0824
R1331 a_n1292_n2000.n0 a_n1292_n2000.t1 0.0824
R1332 a_n1292_n2000.n12 a_n1292_n2000.n10 0.0478684
R1333 a_n1292_n2000.n4 a_n1292_n2000.n3 0.0478684
R1334 a_n1292_n2000.n8 a_n1292_n2000.n6 0.0478684
R1335 a_n3292_n2000.n9 a_n3292_n2000.n8 14.8163
R1336 a_n3292_n2000.n9 a_n3292_n2000.n4 13.9016
R1337 a_n3292_n2000.n10 a_n3292_n2000.n9 13.7637
R1338 a_n3292_n2000.t4 a_n3292_n2000.n12 7.96427
R1339 a_n3292_n2000.n6 a_n3292_n2000.t9 7.96427
R1340 a_n3292_n2000.n3 a_n3292_n2000.t10 7.96426
R1341 a_n3292_n2000.n4 a_n3292_n2000.n1 7.835
R1342 a_n3292_n2000.n8 a_n3292_n2000.n7 7.835
R1343 a_n3292_n2000.n10 a_n3292_n2000.n0 7.835
R1344 a_n3292_n2000.n3 a_n3292_n2000.n2 7.69289
R1345 a_n3292_n2000.n6 a_n3292_n2000.n5 7.69289
R1346 a_n3292_n2000.n12 a_n3292_n2000.n11 7.69289
R1347 a_n3292_n2000.n1 a_n3292_n2000.t13 0.0824
R1348 a_n3292_n2000.n1 a_n3292_n2000.t14 0.0824
R1349 a_n3292_n2000.n2 a_n3292_n2000.t11 0.0824
R1350 a_n3292_n2000.n2 a_n3292_n2000.t12 0.0824
R1351 a_n3292_n2000.n5 a_n3292_n2000.t7 0.0824
R1352 a_n3292_n2000.n5 a_n3292_n2000.t8 0.0824
R1353 a_n3292_n2000.n7 a_n3292_n2000.t5 0.0824
R1354 a_n3292_n2000.n7 a_n3292_n2000.t6 0.0824
R1355 a_n3292_n2000.n11 a_n3292_n2000.t2 0.0824
R1356 a_n3292_n2000.n11 a_n3292_n2000.t3 0.0824
R1357 a_n3292_n2000.n0 a_n3292_n2000.t0 0.0824
R1358 a_n3292_n2000.n0 a_n3292_n2000.t1 0.0824
R1359 a_n3292_n2000.n12 a_n3292_n2000.n10 0.0478684
R1360 a_n3292_n2000.n4 a_n3292_n2000.n3 0.0478684
R1361 a_n3292_n2000.n8 a_n3292_n2000.n6 0.0478684
R1362 a_10284_6400.n2 a_10284_6400.t5 21.0371
R1363 a_10284_6400.n1 a_10284_6400.t0 7.94717
R1364 a_10284_6400.n3 a_10284_6400.n2 7.80881
R1365 a_10284_6400.n1 a_10284_6400.n0 7.6667
R1366 a_10284_6400.n0 a_10284_6400.t2 0.0915
R1367 a_10284_6400.n0 a_10284_6400.t1 0.0915
R1368 a_10284_6400.t4 a_10284_6400.n3 0.0915
R1369 a_10284_6400.n3 a_10284_6400.t3 0.0915
R1370 a_10284_6400.n2 a_10284_6400.n1 0.0478684
R1371 a_9004_6400.n2 a_9004_6400.t5 21.0371
R1372 a_9004_6400.n1 a_9004_6400.t0 7.94717
R1373 a_9004_6400.n3 a_9004_6400.n2 7.80881
R1374 a_9004_6400.n1 a_9004_6400.n0 7.6667
R1375 a_9004_6400.n0 a_9004_6400.t2 0.0915
R1376 a_9004_6400.n0 a_9004_6400.t1 0.0915
R1377 a_9004_6400.t4 a_9004_6400.n3 0.0915
R1378 a_9004_6400.n3 a_9004_6400.t3 0.0915
R1379 a_9004_6400.n2 a_9004_6400.n1 0.0478684
R1380 a_7724_6400.n2 a_7724_6400.t5 21.0371
R1381 a_7724_6400.n1 a_7724_6400.t0 7.94717
R1382 a_7724_6400.n3 a_7724_6400.n2 7.80881
R1383 a_7724_6400.n1 a_7724_6400.n0 7.6667
R1384 a_7724_6400.n0 a_7724_6400.t2 0.0915
R1385 a_7724_6400.n0 a_7724_6400.t1 0.0915
R1386 a_7724_6400.t4 a_7724_6400.n3 0.0915
R1387 a_7724_6400.n3 a_7724_6400.t3 0.0915
R1388 a_7724_6400.n2 a_7724_6400.n1 0.0478684
R1389 a_6444_6400.n2 a_6444_6400.t5 21.0371
R1390 a_6444_6400.n1 a_6444_6400.t0 7.94717
R1391 a_6444_6400.n3 a_6444_6400.n2 7.80881
R1392 a_6444_6400.n1 a_6444_6400.n0 7.6667
R1393 a_6444_6400.n0 a_6444_6400.t2 0.0915
R1394 a_6444_6400.n0 a_6444_6400.t1 0.0915
R1395 a_6444_6400.t4 a_6444_6400.n3 0.0915
R1396 a_6444_6400.n3 a_6444_6400.t3 0.0915
R1397 a_6444_6400.n2 a_6444_6400.n1 0.0478684
R1398 a_5164_6400.n2 a_5164_6400.t5 21.0371
R1399 a_5164_6400.n1 a_5164_6400.t0 7.94717
R1400 a_5164_6400.n3 a_5164_6400.n2 7.80881
R1401 a_5164_6400.n1 a_5164_6400.n0 7.6667
R1402 a_5164_6400.n0 a_5164_6400.t2 0.0915
R1403 a_5164_6400.n0 a_5164_6400.t1 0.0915
R1404 a_5164_6400.t4 a_5164_6400.n3 0.0915
R1405 a_5164_6400.n3 a_5164_6400.t3 0.0915
R1406 a_5164_6400.n2 a_5164_6400.n1 0.0478684
R1407 a_3884_6400.n2 a_3884_6400.t0 21.0371
R1408 a_3884_6400.n1 a_3884_6400.t1 7.94717
R1409 a_3884_6400.n3 a_3884_6400.n2 7.80881
R1410 a_3884_6400.n1 a_3884_6400.n0 7.6667
R1411 a_3884_6400.n0 a_3884_6400.t3 0.0915
R1412 a_3884_6400.n0 a_3884_6400.t2 0.0915
R1413 a_3884_6400.n3 a_3884_6400.t5 0.0915
R1414 a_3884_6400.t4 a_3884_6400.n3 0.0915
R1415 a_3884_6400.n2 a_3884_6400.n1 0.0478684
R1416 a_2604_6400.n2 a_2604_6400.t0 21.0371
R1417 a_2604_6400.n1 a_2604_6400.t1 7.94717
R1418 a_2604_6400.n3 a_2604_6400.n2 7.80881
R1419 a_2604_6400.n1 a_2604_6400.n0 7.6667
R1420 a_2604_6400.n0 a_2604_6400.t3 0.0915
R1421 a_2604_6400.n0 a_2604_6400.t2 0.0915
R1422 a_2604_6400.n3 a_2604_6400.t5 0.0915
R1423 a_2604_6400.t4 a_2604_6400.n3 0.0915
R1424 a_2604_6400.n2 a_2604_6400.n1 0.0478684
R1425 a_1324_6400.n2 a_1324_6400.t5 21.0371
R1426 a_1324_6400.n1 a_1324_6400.t0 7.94717
R1427 a_1324_6400.n3 a_1324_6400.n2 7.80881
R1428 a_1324_6400.n1 a_1324_6400.n0 7.6667
R1429 a_1324_6400.n0 a_1324_6400.t2 0.0915
R1430 a_1324_6400.n0 a_1324_6400.t1 0.0915
R1431 a_1324_6400.t4 a_1324_6400.n3 0.0915
R1432 a_1324_6400.n3 a_1324_6400.t3 0.0915
R1433 a_1324_6400.n2 a_1324_6400.n1 0.0478684
R1434 a_n2196_6400.n2 a_n2196_6400.t5 21.0371
R1435 a_n2196_6400.n1 a_n2196_6400.t0 7.94717
R1436 a_n2196_6400.n3 a_n2196_6400.n2 7.80881
R1437 a_n2196_6400.n1 a_n2196_6400.n0 7.6667
R1438 a_n2196_6400.n0 a_n2196_6400.t2 0.0915
R1439 a_n2196_6400.n0 a_n2196_6400.t1 0.0915
R1440 a_n2196_6400.t4 a_n2196_6400.n3 0.0915
R1441 a_n2196_6400.n3 a_n2196_6400.t3 0.0915
R1442 a_n2196_6400.n2 a_n2196_6400.n1 0.0478684
R1443 a_n3476_6400.n2 a_n3476_6400.t0 21.0371
R1444 a_n3476_6400.n1 a_n3476_6400.t1 7.94717
R1445 a_n3476_6400.n3 a_n3476_6400.n2 7.80881
R1446 a_n3476_6400.n1 a_n3476_6400.n0 7.6667
R1447 a_n3476_6400.n0 a_n3476_6400.t3 0.0915
R1448 a_n3476_6400.n0 a_n3476_6400.t2 0.0915
R1449 a_n3476_6400.n3 a_n3476_6400.t5 0.0915
R1450 a_n3476_6400.t4 a_n3476_6400.n3 0.0915
R1451 a_n3476_6400.n2 a_n3476_6400.n1 0.0478684
R1452 a_n4756_6400.n2 a_n4756_6400.t0 21.0371
R1453 a_n4756_6400.n1 a_n4756_6400.t1 7.94717
R1454 a_n4756_6400.n3 a_n4756_6400.n2 7.80881
R1455 a_n4756_6400.n1 a_n4756_6400.n0 7.6667
R1456 a_n4756_6400.n0 a_n4756_6400.t3 0.0915
R1457 a_n4756_6400.n0 a_n4756_6400.t2 0.0915
R1458 a_n4756_6400.n3 a_n4756_6400.t5 0.0915
R1459 a_n4756_6400.t4 a_n4756_6400.n3 0.0915
R1460 a_n4756_6400.n2 a_n4756_6400.n1 0.0478684
R1461 a_n6036_6400.n2 a_n6036_6400.t5 21.0371
R1462 a_n6036_6400.n1 a_n6036_6400.t0 7.94717
R1463 a_n6036_6400.n3 a_n6036_6400.n2 7.80881
R1464 a_n6036_6400.n1 a_n6036_6400.n0 7.6667
R1465 a_n6036_6400.n0 a_n6036_6400.t2 0.0915
R1466 a_n6036_6400.n0 a_n6036_6400.t1 0.0915
R1467 a_n6036_6400.t4 a_n6036_6400.n3 0.0915
R1468 a_n6036_6400.n3 a_n6036_6400.t3 0.0915
R1469 a_n6036_6400.n2 a_n6036_6400.n1 0.0478684
R1470 a_n7316_6400.n2 a_n7316_6400.t5 21.0371
R1471 a_n7316_6400.n1 a_n7316_6400.t0 7.94717
R1472 a_n7316_6400.n3 a_n7316_6400.n2 7.80881
R1473 a_n7316_6400.n1 a_n7316_6400.n0 7.6667
R1474 a_n7316_6400.n0 a_n7316_6400.t2 0.0915
R1475 a_n7316_6400.n0 a_n7316_6400.t1 0.0915
R1476 a_n7316_6400.t4 a_n7316_6400.n3 0.0915
R1477 a_n7316_6400.n3 a_n7316_6400.t3 0.0915
R1478 a_n7316_6400.n2 a_n7316_6400.n1 0.0478684
R1479 a_n8596_6400.n2 a_n8596_6400.t5 21.0371
R1480 a_n8596_6400.n1 a_n8596_6400.t0 7.94717
R1481 a_n8596_6400.n3 a_n8596_6400.n2 7.80881
R1482 a_n8596_6400.n1 a_n8596_6400.n0 7.6667
R1483 a_n8596_6400.n0 a_n8596_6400.t2 0.0915
R1484 a_n8596_6400.n0 a_n8596_6400.t1 0.0915
R1485 a_n8596_6400.t4 a_n8596_6400.n3 0.0915
R1486 a_n8596_6400.n3 a_n8596_6400.t3 0.0915
R1487 a_n8596_6400.n2 a_n8596_6400.n1 0.0478684
R1488 a_n9876_6400.n2 a_n9876_6400.t5 21.0371
R1489 a_n9876_6400.n1 a_n9876_6400.t0 7.94717
R1490 a_n9876_6400.n3 a_n9876_6400.n2 7.80881
R1491 a_n9876_6400.n1 a_n9876_6400.n0 7.6667
R1492 a_n9876_6400.n0 a_n9876_6400.t2 0.0915
R1493 a_n9876_6400.n0 a_n9876_6400.t1 0.0915
R1494 a_n9876_6400.t4 a_n9876_6400.n3 0.0915
R1495 a_n9876_6400.n3 a_n9876_6400.t3 0.0915
R1496 a_n9876_6400.n2 a_n9876_6400.n1 0.0478684
R1497 a_n11156_6400.n2 a_n11156_6400.t5 21.0371
R1498 a_n11156_6400.n1 a_n11156_6400.t0 7.94717
R1499 a_n11156_6400.n3 a_n11156_6400.n2 7.80881
R1500 a_n11156_6400.n1 a_n11156_6400.n0 7.6667
R1501 a_n11156_6400.n0 a_n11156_6400.t2 0.0915
R1502 a_n11156_6400.n0 a_n11156_6400.t1 0.0915
R1503 a_n11156_6400.t4 a_n11156_6400.n3 0.0915
R1504 a_n11156_6400.n3 a_n11156_6400.t3 0.0915
R1505 a_n11156_6400.n2 a_n11156_6400.n1 0.0478684
C0 VDD OUTN 0.21446f
C1 LOAD_EN0_N LOAD_EN1_N 0.95572f
C2 LOAD_EN2_N VDD 5.2554f
C3 OUTP OUTN 0.01866f
C4 LOAD_EN2_N LOAD_EN1_N 1.53541f
C5 LOAD_EN3_N VDD 24.7465f
C6 LOAD_EN0_N LOAD_EN2_N 0.04666f
C7 LOAD_EN3_N LOAD_EN1_N 0.04209f
C8 OUTP ODD_P 1.08183f
C9 OUTN EVEN_N 1.09302f
C10 OUTP EVEN_P 1.09319f
C11 LOAD_EN0_N LOAD_EN3_N 0.04122f
C12 LOAD_EN3_N LOAD_EN2_N 1.46836f
C13 OUTN ODD_N 1.08201f
C14 VDD LOAD_EN1_N 5.67637f
C15 OUTP VDD 0.21446f
C16 LOAD_EN0_N VDD 4.91361f
C17 VBIAS VSS 6.29454f
C18 CLK_N VSS 1.23919f
C19 CLK_P VSS 1.23916f
C20 EVEN_N VSS 1.29162f
C21 ODD_N VSS 1.28597f
C22 ODD_P VSS 1.28592f
C23 EVEN_P VSS 1.29162f
C24 OUTN VSS 10.75478f
C25 OUTP VSS 10.89629f
C26 LOAD_EN0_N VSS 1.65091f
C27 LOAD_EN1_N VSS 3.06804f
C28 LOAD_EN2_N VSS 4.77221f
C29 LOAD_EN3_N VSS 8.67953f
C30 VDD VSS 0.29542p
C31 a_n11156_6400.t3 VSS 0.61344f
C32 a_n11156_6400.t0 VSS 2.30836f
C33 a_n11156_6400.t2 VSS 0.61344f
C34 a_n11156_6400.t1 VSS 0.61344f
C35 a_n11156_6400.n0 VSS 1.54175f
C36 a_n11156_6400.n1 VSS 0.5362f
C37 a_n11156_6400.t5 VSS 1.2116f
C38 a_n11156_6400.n2 VSS 3.68278f
C39 a_n11156_6400.n3 VSS 1.54626f
C40 a_n11156_6400.t4 VSS 0.61465f
C41 a_n9876_6400.t3 VSS 0.62466f
C42 a_n9876_6400.t0 VSS 2.36389f
C43 a_n9876_6400.t2 VSS 0.62466f
C44 a_n9876_6400.t1 VSS 0.62466f
C45 a_n9876_6400.n0 VSS 1.58208f
C46 a_n9876_6400.n1 VSS 0.55023f
C47 a_n9876_6400.t5 VSS 1.2433f
C48 a_n9876_6400.n2 VSS 3.77912f
C49 a_n9876_6400.n3 VSS 1.58671f
C50 a_n9876_6400.t4 VSS 0.62587f
C51 a_n8596_6400.t3 VSS 0.62466f
C52 a_n8596_6400.t0 VSS 2.36389f
C53 a_n8596_6400.t2 VSS 0.62466f
C54 a_n8596_6400.t1 VSS 0.62466f
C55 a_n8596_6400.n0 VSS 1.58208f
C56 a_n8596_6400.n1 VSS 0.55023f
C57 a_n8596_6400.t5 VSS 1.2433f
C58 a_n8596_6400.n2 VSS 3.77912f
C59 a_n8596_6400.n3 VSS 1.58671f
C60 a_n8596_6400.t4 VSS 0.62587f
C61 a_n7316_6400.t3 VSS 0.62468f
C62 a_n7316_6400.t0 VSS 2.36399f
C63 a_n7316_6400.t2 VSS 0.62468f
C64 a_n7316_6400.t1 VSS 0.62468f
C65 a_n7316_6400.n0 VSS 1.58216f
C66 a_n7316_6400.n1 VSS 0.55025f
C67 a_n7316_6400.t5 VSS 1.24335f
C68 a_n7316_6400.n2 VSS 3.7793f
C69 a_n7316_6400.n3 VSS 1.58679f
C70 a_n7316_6400.t4 VSS 0.62589f
C71 a_n6036_6400.t3 VSS 0.62441f
C72 a_n6036_6400.t0 VSS 2.36265f
C73 a_n6036_6400.t2 VSS 0.62441f
C74 a_n6036_6400.t1 VSS 0.62441f
C75 a_n6036_6400.n0 VSS 1.58118f
C76 a_n6036_6400.n1 VSS 0.54991f
C77 a_n6036_6400.t5 VSS 1.24259f
C78 a_n6036_6400.n2 VSS 3.77697f
C79 a_n6036_6400.n3 VSS 1.58581f
C80 a_n6036_6400.t4 VSS 0.62562f
C81 a_n4756_6400.t5 VSS 0.66406f
C82 a_n4756_6400.t1 VSS 2.40354f
C83 a_n4756_6400.t3 VSS 0.6626f
C84 a_n4756_6400.t2 VSS 0.6626f
C85 a_n4756_6400.n0 VSS 1.58342f
C86 a_n4756_6400.n1 VSS 0.55069f
C87 a_n4756_6400.t0 VSS 1.24434f
C88 a_n4756_6400.n2 VSS 3.78231f
C89 a_n4756_6400.n3 VSS 1.58805f
C90 a_n4756_6400.t4 VSS 0.6626f
C91 a_n3476_6400.t5 VSS 0.68693f
C92 a_n3476_6400.t1 VSS 2.42813f
C93 a_n3476_6400.t3 VSS 0.68532f
C94 a_n3476_6400.t2 VSS 0.68532f
C95 a_n3476_6400.n0 VSS 1.58498f
C96 a_n3476_6400.n1 VSS 0.55124f
C97 a_n3476_6400.t0 VSS 1.24557f
C98 a_n3476_6400.n2 VSS 3.78604f
C99 a_n3476_6400.n3 VSS 1.58962f
C100 a_n3476_6400.t4 VSS 0.68532f
C101 a_n2196_6400.t3 VSS 0.64716f
C102 a_n2196_6400.t0 VSS 2.35223f
C103 a_n2196_6400.t2 VSS 0.64716f
C104 a_n2196_6400.t1 VSS 0.64716f
C105 a_n2196_6400.n0 VSS 1.55082f
C106 a_n2196_6400.n1 VSS 0.53935f
C107 a_n2196_6400.t5 VSS 1.21872f
C108 a_n2196_6400.n2 VSS 3.70443f
C109 a_n2196_6400.n3 VSS 1.55535f
C110 a_n2196_6400.t4 VSS 0.64857f
C111 a_1324_6400.t3 VSS 0.63409f
C112 a_1324_6400.t0 VSS 2.28754f
C113 a_1324_6400.t2 VSS 0.63409f
C114 a_1324_6400.t1 VSS 0.63409f
C115 a_1324_6400.n0 VSS 1.50383f
C116 a_1324_6400.n1 VSS 0.52301f
C117 a_1324_6400.t5 VSS 1.1818f
C118 a_1324_6400.n2 VSS 3.59219f
C119 a_1324_6400.n3 VSS 1.50823f
C120 a_1324_6400.t4 VSS 0.6355f
C121 a_2604_6400.t5 VSS 0.68694f
C122 a_2604_6400.t1 VSS 2.42819f
C123 a_2604_6400.t3 VSS 0.68534f
C124 a_2604_6400.t2 VSS 0.68534f
C125 a_2604_6400.n0 VSS 1.58503f
C126 a_2604_6400.n1 VSS 0.55125f
C127 a_2604_6400.t0 VSS 1.24561f
C128 a_2604_6400.n2 VSS 3.78616f
C129 a_2604_6400.n3 VSS 1.58967f
C130 a_2604_6400.t4 VSS 0.68534f
C131 a_3884_6400.t5 VSS 0.66408f
C132 a_3884_6400.t1 VSS 2.40362f
C133 a_3884_6400.t3 VSS 0.66262f
C134 a_3884_6400.t2 VSS 0.66262f
C135 a_3884_6400.n0 VSS 1.58348f
C136 a_3884_6400.n1 VSS 0.55071f
C137 a_3884_6400.t0 VSS 1.24439f
C138 a_3884_6400.n2 VSS 3.78245f
C139 a_3884_6400.n3 VSS 1.58811f
C140 a_3884_6400.t4 VSS 0.66262f
C141 a_5164_6400.t3 VSS 0.62476f
C142 a_5164_6400.t0 VSS 2.36438f
C143 a_5164_6400.t2 VSS 0.62476f
C144 a_5164_6400.t1 VSS 0.62476f
C145 a_5164_6400.n0 VSS 1.58244f
C146 a_5164_6400.n1 VSS 0.55035f
C147 a_5164_6400.t5 VSS 1.24358f
C148 a_5164_6400.n2 VSS 3.77998f
C149 a_5164_6400.n3 VSS 1.58707f
C150 a_5164_6400.t4 VSS 0.62597f
C151 a_6444_6400.t3 VSS 0.62537f
C152 a_6444_6400.t0 VSS 2.36737f
C153 a_6444_6400.t2 VSS 0.62537f
C154 a_6444_6400.t1 VSS 0.62537f
C155 a_6444_6400.n0 VSS 1.58462f
C156 a_6444_6400.n1 VSS 0.55111f
C157 a_6444_6400.t5 VSS 1.24529f
C158 a_6444_6400.n2 VSS 3.78517f
C159 a_6444_6400.n3 VSS 1.58925f
C160 a_6444_6400.t4 VSS 0.62658f
C161 a_7724_6400.t3 VSS 0.62466f
C162 a_7724_6400.t0 VSS 2.36389f
C163 a_7724_6400.t2 VSS 0.62466f
C164 a_7724_6400.t1 VSS 0.62466f
C165 a_7724_6400.n0 VSS 1.58208f
C166 a_7724_6400.n1 VSS 0.55023f
C167 a_7724_6400.t5 VSS 1.2433f
C168 a_7724_6400.n2 VSS 3.77912f
C169 a_7724_6400.n3 VSS 1.58671f
C170 a_7724_6400.t4 VSS 0.62587f
C171 a_9004_6400.t3 VSS 0.62466f
C172 a_9004_6400.t0 VSS 2.36389f
C173 a_9004_6400.t2 VSS 0.62466f
C174 a_9004_6400.t1 VSS 0.62466f
C175 a_9004_6400.n0 VSS 1.58208f
C176 a_9004_6400.n1 VSS 0.55023f
C177 a_9004_6400.t5 VSS 1.2433f
C178 a_9004_6400.n2 VSS 3.77912f
C179 a_9004_6400.n3 VSS 1.58671f
C180 a_9004_6400.t4 VSS 0.62587f
C181 a_10284_6400.t3 VSS 0.62493f
C182 a_10284_6400.t0 VSS 2.36519f
C183 a_10284_6400.t2 VSS 0.62493f
C184 a_10284_6400.t1 VSS 0.62493f
C185 a_10284_6400.n0 VSS 1.58304f
C186 a_10284_6400.n1 VSS 0.55056f
C187 a_10284_6400.t5 VSS 1.24404f
C188 a_10284_6400.n2 VSS 3.78139f
C189 a_10284_6400.n3 VSS 1.58767f
C190 a_10284_6400.t4 VSS 0.62614f
C191 a_n3292_n2000.t1 VSS 0.59902f
C192 a_n3292_n2000.t0 VSS 0.59902f
C193 a_n3292_n2000.n0 VSS 1.66501f
C194 a_n3292_n2000.t14 VSS 0.5987f
C195 a_n3292_n2000.t13 VSS 0.59781f
C196 a_n3292_n2000.n1 VSS 1.66501f
C197 a_n3292_n2000.t10 VSS 2.42402f
C198 a_n3292_n2000.t12 VSS 0.59781f
C199 a_n3292_n2000.t11 VSS 0.59781f
C200 a_n3292_n2000.n2 VSS 1.66012f
C201 a_n3292_n2000.n3 VSS 0.58104f
C202 a_n3292_n2000.n4 VSS 0.4951f
C203 a_n3292_n2000.t9 VSS 2.4262f
C204 a_n3292_n2000.t8 VSS 0.5991f
C205 a_n3292_n2000.t7 VSS 0.5991f
C206 a_n3292_n2000.n5 VSS 1.66012f
C207 a_n3292_n2000.n6 VSS 0.58104f
C208 a_n3292_n2000.t6 VSS 0.5991f
C209 a_n3292_n2000.t5 VSS 0.5991f
C210 a_n3292_n2000.n7 VSS 1.66501f
C211 a_n3292_n2000.n8 VSS 0.63959f
C212 a_n3292_n2000.n9 VSS 5.35712f
C213 a_n3292_n2000.n10 VSS 0.4852f
C214 a_n3292_n2000.t3 VSS 0.59902f
C215 a_n3292_n2000.t2 VSS 0.59902f
C216 a_n3292_n2000.n11 VSS 1.66012f
C217 a_n3292_n2000.n12 VSS 0.58104f
C218 a_n3292_n2000.t4 VSS 2.42612f
C219 a_n1292_n2000.t1 VSS 0.63924f
C220 a_n1292_n2000.t0 VSS 0.63924f
C221 a_n1292_n2000.n0 VSS 1.802f
C222 a_n1292_n2000.t14 VSS 0.63743f
C223 a_n1292_n2000.t13 VSS 0.63653f
C224 a_n1292_n2000.n1 VSS 1.802f
C225 a_n1292_n2000.t10 VSS 2.61299f
C226 a_n1292_n2000.t12 VSS 0.63653f
C227 a_n1292_n2000.t11 VSS 0.63653f
C228 a_n1292_n2000.n2 VSS 1.7967f
C229 a_n1292_n2000.n3 VSS 0.62885f
C230 a_n1292_n2000.n4 VSS 0.6098f
C231 a_n1292_n2000.t9 VSS 2.61574f
C232 a_n1292_n2000.t8 VSS 0.63839f
C233 a_n1292_n2000.t7 VSS 0.63839f
C234 a_n1292_n2000.n5 VSS 1.7967f
C235 a_n1292_n2000.n6 VSS 0.62885f
C236 a_n1292_n2000.t6 VSS 0.63839f
C237 a_n1292_n2000.t5 VSS 0.63839f
C238 a_n1292_n2000.n7 VSS 1.802f
C239 a_n1292_n2000.n8 VSS 0.55734f
C240 a_n1292_n2000.n9 VSS 3.39563f
C241 a_n1292_n2000.n10 VSS 0.45932f
C242 a_n1292_n2000.t3 VSS 0.63924f
C243 a_n1292_n2000.t2 VSS 0.63924f
C244 a_n1292_n2000.n11 VSS 1.7967f
C245 a_n1292_n2000.n12 VSS 0.62885f
C246 a_n1292_n2000.t4 VSS 2.61661f
C247 a_n2292_n6800.n0 VSS 0.5769f
C248 a_n2292_n6800.t10 VSS 0.2898f
C249 a_n2292_n6800.t9 VSS 0.2898f
C250 a_n2292_n6800.n1 VSS 0.77701f
C251 a_n2292_n6800.t6 VSS 0.2898f
C252 a_n2292_n6800.t5 VSS 0.2898f
C253 a_n2292_n6800.n2 VSS 0.77701f
C254 a_n2292_n6800.t4 VSS 0.2898f
C255 a_n2292_n6800.t3 VSS 0.2898f
C256 a_n2292_n6800.n3 VSS 0.77701f
C257 a_n2292_n6800.n4 VSS 0.16548f
C258 a_n2292_n6800.t20 VSS 0.35172f
C259 a_n2292_n6800.t19 VSS 0.35172f
C260 a_n2292_n6800.n5 VSS 0.78355f
C261 a_n2292_n6800.n6 VSS 0.16369f
C262 a_n2292_n6800.t21 VSS 1.20852f
C263 a_n2292_n6800.t23 VSS 0.35172f
C264 a_n2292_n6800.t22 VSS 0.35172f
C265 a_n2292_n6800.n7 VSS 0.78176f
C266 a_n2292_n6800.n8 VSS 0.1688f
C267 a_n2292_n6800.n9 VSS 0.15135f
C268 a_n2292_n6800.n10 VSS 0.7812f
C269 a_n2292_n6800.t17 VSS 1.21104f
C270 a_n2292_n6800.n11 VSS 0.16671f
C271 a_n2292_n6800.t16 VSS 0.35238f
C272 a_n2292_n6800.t15 VSS 0.35238f
C273 a_n2292_n6800.n12 VSS 0.78176f
C274 a_n2292_n6800.n13 VSS 0.1688f
C275 a_n2292_n6800.t14 VSS 0.35238f
C276 a_n2292_n6800.t18 VSS 0.35238f
C277 a_n2292_n6800.n14 VSS 0.78176f
C278 a_n2292_n6800.n15 VSS 0.14222f
C279 a_n2292_n6800.n16 VSS 0.74727f
C280 a_n2292_n6800.n17 VSS 1.30581f
C281 a_n2292_n6800.n18 VSS 0.62625f
C282 a_n2292_n6800.t0 VSS 1.14503f
C283 a_n2292_n6800.t2 VSS 0.2898f
C284 a_n2292_n6800.t1 VSS 0.2898f
C285 a_n2292_n6800.n19 VSS 0.77701f
C286 a_n2292_n6800.n20 VSS 0.33573f
C287 a_n2292_n6800.n21 VSS 0.64875f
C288 a_n2292_n6800.n22 VSS 0.16548f
C289 a_n2292_n6800.t8 VSS 0.2898f
C290 a_n2292_n6800.t7 VSS 0.2898f
C291 a_n2292_n6800.n23 VSS 0.77701f
C292 a_n2292_n6800.n24 VSS 0.16548f
C293 a_n2292_n6800.n25 VSS 0.16548f
C294 a_n2292_n6800.t12 VSS 0.2898f
C295 a_n2292_n6800.t11 VSS 0.2898f
C296 a_n2292_n6800.n26 VSS 0.77701f
C297 a_n2292_n6800.n27 VSS 0.16548f
C298 a_n2292_n6800.n28 VSS 0.16567f
C299 a_n2292_n6800.t13 VSS 1.14151f
C300 VSS.t36 VSS 0.07328f
C301 VSS.t32 VSS 0.07376f
C302 VSS.t58 VSS 0.07376f
C303 VSS.t56 VSS 0.07328f
C304 VSS.t54 VSS 0.07328f
C305 VSS.t52 VSS 0.07328f
C306 VSS.t44 VSS 0.07328f
C307 VSS.t50 VSS 0.07328f
C308 VSS.t48 VSS 0.07328f
C309 VSS.t46 VSS 0.07328f
C310 VSS.t42 VSS 0.07328f
C311 VSS.t40 VSS 0.07328f
C312 VSS.t38 VSS 0.07328f
C313 VSS.t34 VSS 0.07328f
C314 VDD.n0 VSS 0.35828f
C315 VDD.n1 VSS 0.22658f
C316 VDD.t108 VSS 0.36907f
C317 VDD.t106 VSS 0.36907f
C318 VDD.n2 VSS 0.55137f
C319 VDD.n3 VSS 0.10415f
C320 VDD.t111 VSS 2.36477f
C321 VDD.t114 VSS 0.36907f
C322 VDD.t118 VSS 0.36907f
C323 VDD.n4 VSS 0.55137f
C324 VDD.n5 VSS 0.10415f
C325 VDD.n6 VSS 0.22658f
C326 VDD.n7 VSS 0.02549f
C327 VDD.t144 VSS 1.66395f
C328 VDD.n8 VSS 0.02549f
C329 VDD.n9 VSS 0.22658f
C330 VDD.n10 VSS 0.02549f
C331 VDD.t60 VSS 1.52529f
C332 VDD.n11 VSS 0.02549f
C333 VDD.n12 VSS 0.22658f
C334 VDD.n13 VSS 0.02549f
C335 VDD.t80 VSS 1.66395f
C336 VDD.n14 VSS 0.02549f
C337 VDD.n15 VSS 0.21313f
C338 VDD.n16 VSS 0.02549f
C339 VDD.t141 VSS 0.23357f
C340 VDD.n17 VSS 2.93004f
C341 VDD.t93 VSS 0.33787f
C342 VDD.t97 VSS 0.33787f
C343 VDD.n18 VSS 0.55137f
C344 VDD.n19 VSS 0.10415f
C345 VDD.t99 VSS 0.9423f
C346 VDD.n20 VSS 0.15096f
C347 VDD.n21 VSS 2.63428f
C348 VDD.t98 VSS 2.22781f
C349 VDD.t92 VSS 1.1093f
C350 VDD.t96 VSS 1.1093f
C351 VDD.t94 VSS 1.1093f
C352 VDD.t90 VSS 1.66395f
C353 VDD.t84 VSS 1.1093f
C354 VDD.t86 VSS 1.1093f
C355 VDD.t82 VSS 1.1093f
C356 VDD.t88 VSS 1.66395f
C357 VDD.n22 VSS 2.24861f
C358 VDD.t83 VSS 0.33787f
C359 VDD.t87 VSS 0.33787f
C360 VDD.n23 VSS 0.55137f
C361 VDD.n24 VSS 0.10415f
C362 VDD.t89 VSS 0.9423f
C363 VDD.n25 VSS 0.15096f
C364 VDD.n26 VSS 0.19105f
C365 VDD.t95 VSS 0.33787f
C366 VDD.t91 VSS 0.33908f
C367 VDD.n27 VSS 0.55137f
C368 VDD.n28 VSS 0.14663f
C369 VDD.n29 VSS 0.05381f
C370 VDD.n30 VSS 0.22658f
C371 VDD.n31 VSS 0.22658f
C372 VDD.n32 VSS 0.22658f
C373 VDD.n33 VSS 0.05381f
C374 VDD.t85 VSS 0.33787f
C375 VDD.t81 VSS 0.33908f
C376 VDD.n34 VSS 0.55137f
C377 VDD.n35 VSS 0.14663f
C378 VDD.t75 VSS 0.33787f
C379 VDD.t79 VSS 0.33787f
C380 VDD.n36 VSS 0.55137f
C381 VDD.n37 VSS 0.10415f
C382 VDD.t73 VSS 0.9423f
C383 VDD.n38 VSS 0.15096f
C384 VDD.n39 VSS 0.19105f
C385 VDD.n40 VSS 2.24861f
C386 VDD.t72 VSS 1.66395f
C387 VDD.t74 VSS 1.1093f
C388 VDD.t78 VSS 1.1093f
C389 VDD.t76 VSS 1.1093f
C390 VDD.t70 VSS 1.66395f
C391 VDD.t64 VSS 1.1093f
C392 VDD.t66 VSS 1.1093f
C393 VDD.t62 VSS 1.1093f
C394 VDD.t68 VSS 1.66395f
C395 VDD.n41 VSS 2.24861f
C396 VDD.t63 VSS 0.33787f
C397 VDD.t67 VSS 0.33787f
C398 VDD.n42 VSS 0.55137f
C399 VDD.n43 VSS 0.10415f
C400 VDD.t69 VSS 0.9423f
C401 VDD.n44 VSS 0.15096f
C402 VDD.n45 VSS 0.19105f
C403 VDD.t77 VSS 0.33787f
C404 VDD.t71 VSS 0.33908f
C405 VDD.n46 VSS 0.55137f
C406 VDD.n47 VSS 0.14663f
C407 VDD.n48 VSS 0.05381f
C408 VDD.n49 VSS 0.22658f
C409 VDD.n50 VSS 0.22658f
C410 VDD.n51 VSS 0.22658f
C411 VDD.n52 VSS 0.05381f
C412 VDD.t65 VSS 0.33787f
C413 VDD.t61 VSS 0.33908f
C414 VDD.n53 VSS 0.55137f
C415 VDD.n54 VSS 0.13955f
C416 VDD.t57 VSS 0.33787f
C417 VDD.t55 VSS 0.33787f
C418 VDD.n55 VSS 0.55137f
C419 VDD.n56 VSS 0.10415f
C420 VDD.t59 VSS 0.9423f
C421 VDD.n57 VSS 0.15804f
C422 VDD.n58 VSS 0.19105f
C423 VDD.n59 VSS 2.24861f
C424 VDD.t58 VSS 1.80262f
C425 VDD.t56 VSS 1.1093f
C426 VDD.t54 VSS 1.1093f
C427 VDD.t52 VSS 1.1093f
C428 VDD.t0 VSS 1.66395f
C429 VDD.t156 VSS 1.1093f
C430 VDD.t158 VSS 1.1093f
C431 VDD.t154 VSS 1.1093f
C432 VDD.t160 VSS 1.66395f
C433 VDD.n60 VSS 2.24861f
C434 VDD.t155 VSS 0.37545f
C435 VDD.t159 VSS 0.37545f
C436 VDD.n61 VSS 0.55137f
C437 VDD.n62 VSS 0.10415f
C438 VDD.t161 VSS 0.98012f
C439 VDD.n63 VSS 0.15096f
C440 VDD.n64 VSS 0.19105f
C441 VDD.t53 VSS 0.33787f
C442 VDD.t1 VSS 0.33908f
C443 VDD.n65 VSS 0.55137f
C444 VDD.n66 VSS 0.14663f
C445 VDD.n67 VSS 0.05381f
C446 VDD.n68 VSS 0.22658f
C447 VDD.n69 VSS 0.22658f
C448 VDD.n70 VSS 0.22658f
C449 VDD.n71 VSS 0.05381f
C450 VDD.t157 VSS 0.37545f
C451 VDD.t145 VSS 0.3769f
C452 VDD.n72 VSS 0.55137f
C453 VDD.n73 VSS 0.14663f
C454 VDD.t138 VSS 0.39773f
C455 VDD.t136 VSS 0.39773f
C456 VDD.n74 VSS 0.55137f
C457 VDD.n75 VSS 0.10415f
C458 VDD.t140 VSS 1.00255f
C459 VDD.n76 VSS 0.15096f
C460 VDD.n77 VSS 0.19105f
C461 VDD.n78 VSS 2.24861f
C462 VDD.t139 VSS 1.66395f
C463 VDD.t137 VSS 1.1093f
C464 VDD.t135 VSS 1.1093f
C465 VDD.t133 VSS 1.1093f
C466 VDD.t121 VSS 1.66395f
C467 VDD.t115 VSS 1.1093f
C468 VDD.t117 VSS 1.1093f
C469 VDD.t113 VSS 1.1093f
C470 VDD.t119 VSS 1.66395f
C471 VDD.n79 VSS 2.24861f
C472 VDD.t120 VSS 0.9737f
C473 VDD.n80 VSS 0.15096f
C474 VDD.n81 VSS 0.19105f
C475 VDD.t134 VSS 0.39773f
C476 VDD.t122 VSS 0.39933f
C477 VDD.n82 VSS 0.55137f
C478 VDD.n83 VSS 0.14663f
C479 VDD.n84 VSS 0.05381f
C480 VDD.n85 VSS 0.22658f
C481 VDD.n86 VSS 0.22658f
C482 VDD.n87 VSS 0.02549f
C483 VDD.n88 VSS 0.05381f
C484 VDD.t116 VSS 0.36907f
C485 VDD.t112 VSS 0.37049f
C486 VDD.n89 VSS 0.55137f
C487 VDD.n90 VSS 0.16079f
C488 VDD.n91 VSS 2.63337f
C489 VDD.t110 VSS 0.9737f
C490 VDD.n92 VSS 0.16512f
C491 VDD.n93 VSS 2.60505f
C492 VDD.t109 VSS 2.36477f
C493 VDD.t107 VSS 1.1093f
C494 VDD.t105 VSS 1.1093f
C495 VDD.t101 VSS 1.1093f
C496 VDD.t103 VSS 1.66395f
C497 VDD.n94 VSS 2.24861f
C498 VDD.n95 VSS 0.05381f
C499 VDD.n96 VSS 0.22658f
C500 VDD.t151 VSS 0.37545f
C501 VDD.t149 VSS 0.37545f
C502 VDD.n97 VSS 0.55137f
C503 VDD.n98 VSS 0.10415f
C504 VDD.t131 VSS 1.66395f
C505 VDD.t129 VSS 1.1093f
C506 VDD.t127 VSS 1.1093f
C507 VDD.t123 VSS 1.1093f
C508 VDD.t125 VSS 1.66395f
C509 VDD.t124 VSS 0.39773f
C510 VDD.t126 VSS 0.39933f
C511 VDD.n99 VSS 0.55137f
C512 VDD.n100 VSS 0.14663f
C513 VDD.t153 VSS 0.98012f
C514 VDD.n101 VSS 0.15096f
C515 VDD.n102 VSS 0.19105f
C516 VDD.n103 VSS 2.24861f
C517 VDD.t152 VSS 1.66395f
C518 VDD.t150 VSS 1.1093f
C519 VDD.t148 VSS 1.1093f
C520 VDD.t142 VSS 1.1093f
C521 VDD.t146 VSS 1.66395f
C522 VDD.n104 VSS 2.24861f
C523 VDD.n105 VSS 0.05381f
C524 VDD.n106 VSS 0.22658f
C525 VDD.t41 VSS 0.33787f
C526 VDD.t39 VSS 0.33787f
C527 VDD.n107 VSS 0.55137f
C528 VDD.n108 VSS 0.10415f
C529 VDD.t50 VSS 1.66395f
C530 VDD.t48 VSS 1.1093f
C531 VDD.t46 VSS 1.1093f
C532 VDD.t44 VSS 1.1093f
C533 VDD.t12 VSS 1.80262f
C534 VDD.t45 VSS 0.33787f
C535 VDD.t13 VSS 0.33908f
C536 VDD.n109 VSS 0.55137f
C537 VDD.n110 VSS 0.15371f
C538 VDD.t43 VSS 0.9423f
C539 VDD.n111 VSS 0.14388f
C540 VDD.n112 VSS 0.19105f
C541 VDD.n113 VSS 2.24861f
C542 VDD.t42 VSS 1.52529f
C543 VDD.t40 VSS 1.1093f
C544 VDD.t38 VSS 1.1093f
C545 VDD.t2 VSS 1.1093f
C546 VDD.t36 VSS 1.66395f
C547 VDD.n114 VSS 2.24861f
C548 VDD.n115 VSS 0.05381f
C549 VDD.n116 VSS 0.22658f
C550 VDD.t25 VSS 0.33787f
C551 VDD.t23 VSS 0.33787f
C552 VDD.n117 VSS 0.55137f
C553 VDD.n118 VSS 0.10415f
C554 VDD.t34 VSS 1.66395f
C555 VDD.t32 VSS 1.1093f
C556 VDD.t30 VSS 1.1093f
C557 VDD.t28 VSS 1.1093f
C558 VDD.t8 VSS 1.66395f
C559 VDD.t29 VSS 0.33787f
C560 VDD.t9 VSS 0.33908f
C561 VDD.n119 VSS 0.55137f
C562 VDD.n120 VSS 0.14663f
C563 VDD.t27 VSS 0.9423f
C564 VDD.n121 VSS 0.15096f
C565 VDD.n122 VSS 0.19105f
C566 VDD.n123 VSS 2.24861f
C567 VDD.t26 VSS 1.66395f
C568 VDD.t24 VSS 1.1093f
C569 VDD.t22 VSS 1.1093f
C570 VDD.t6 VSS 1.1093f
C571 VDD.t10 VSS 1.66395f
C572 VDD.n124 VSS 2.24861f
C573 VDD.n125 VSS 0.05381f
C574 VDD.t100 VSS 0.23357f
C575 VDD.t20 VSS 1.66395f
C576 VDD.t18 VSS 1.1093f
C577 VDD.t16 VSS 1.1093f
C578 VDD.t4 VSS 1.1093f
C579 VDD.t14 VSS 2.22781f
C580 VDD.t5 VSS 0.33787f
C581 VDD.t15 VSS 0.33908f
C582 VDD.n126 VSS 0.55137f
C583 VDD.n127 VSS 0.14663f
C584 VDD.n128 VSS 2.6626f
C585 VDD.n129 VSS 2.93004f
C586 VDD.n130 VSS 0.21313f
C587 VDD.n131 VSS 0.22658f
C588 VDD.n132 VSS 0.02549f
C589 VDD.t19 VSS 0.33787f
C590 VDD.t17 VSS 0.33787f
C591 VDD.n133 VSS 0.55137f
C592 VDD.n134 VSS 0.10415f
C593 VDD.t21 VSS 0.9423f
C594 VDD.n135 VSS 0.15096f
C595 VDD.n136 VSS 0.19105f
C596 VDD.t7 VSS 0.33787f
C597 VDD.t11 VSS 0.33908f
C598 VDD.n137 VSS 0.55137f
C599 VDD.n138 VSS 0.14663f
C600 VDD.n139 VSS 0.05381f
C601 VDD.n140 VSS 0.02549f
C602 VDD.n141 VSS 0.22658f
C603 VDD.n142 VSS 0.22658f
C604 VDD.n143 VSS 0.22658f
C605 VDD.n144 VSS 0.02549f
C606 VDD.t33 VSS 0.33787f
C607 VDD.t31 VSS 0.33787f
C608 VDD.n145 VSS 0.55137f
C609 VDD.n146 VSS 0.10415f
C610 VDD.t35 VSS 0.9423f
C611 VDD.n147 VSS 0.15096f
C612 VDD.n148 VSS 0.19105f
C613 VDD.t3 VSS 0.33787f
C614 VDD.t37 VSS 0.33908f
C615 VDD.n149 VSS 0.55137f
C616 VDD.n150 VSS 0.14663f
C617 VDD.n151 VSS 0.05381f
C618 VDD.n152 VSS 0.02549f
C619 VDD.n153 VSS 0.22658f
C620 VDD.n154 VSS 0.22658f
C621 VDD.n155 VSS 0.22658f
C622 VDD.n156 VSS 0.02549f
C623 VDD.t49 VSS 0.33787f
C624 VDD.t47 VSS 0.33787f
C625 VDD.n157 VSS 0.55137f
C626 VDD.n158 VSS 0.10415f
C627 VDD.t51 VSS 0.9423f
C628 VDD.n159 VSS 0.15096f
C629 VDD.n160 VSS 0.19105f
C630 VDD.t143 VSS 0.37545f
C631 VDD.t147 VSS 0.3769f
C632 VDD.n161 VSS 0.55137f
C633 VDD.n162 VSS 0.14663f
C634 VDD.n163 VSS 0.05381f
C635 VDD.n164 VSS 0.02549f
C636 VDD.n165 VSS 0.22658f
C637 VDD.n166 VSS 0.22658f
C638 VDD.n167 VSS 0.22658f
C639 VDD.n168 VSS 0.02549f
C640 VDD.t130 VSS 0.39773f
C641 VDD.t128 VSS 0.39773f
C642 VDD.n169 VSS 0.55137f
C643 VDD.n170 VSS 0.10415f
C644 VDD.t132 VSS 1.00255f
C645 VDD.n171 VSS 0.15096f
C646 VDD.n172 VSS 0.19105f
C647 VDD.t102 VSS 0.36907f
C648 VDD.t104 VSS 0.37049f
C649 VDD.n173 VSS 0.55137f
C650 VDD.n174 VSS 0.14663f
C651 VDD.n175 VSS 0.05381f
C652 VDD.n176 VSS 0.02549f
C653 VDD.n177 VSS 0.28748f
C654 LOAD_EN3_N.n0 VSS 0.14571f
C655 LOAD_EN3_N.n1 VSS 0.15065f
C656 LOAD_EN3_N.n2 VSS 0.15065f
C657 LOAD_EN3_N.n3 VSS 0.15065f
C658 LOAD_EN3_N.n4 VSS 0.14571f
C659 LOAD_EN3_N.n5 VSS 0.33761f
C660 LOAD_EN3_N.n6 VSS 0.14571f
C661 LOAD_EN3_N.n7 VSS 0.15065f
C662 LOAD_EN3_N.n8 VSS 0.15065f
C663 LOAD_EN3_N.n9 VSS 0.15065f
C664 LOAD_EN3_N.n10 VSS 0.14571f
C665 LOAD_EN3_N.n11 VSS 0.33167f
C666 LOAD_EN3_N.n12 VSS 0.75926f
C667 LOAD_EN3_N.n13 VSS 0.14571f
C668 LOAD_EN3_N.n14 VSS 0.15065f
C669 LOAD_EN3_N.n15 VSS 0.15065f
C670 LOAD_EN3_N.n16 VSS 0.15065f
C671 LOAD_EN3_N.n17 VSS 0.14571f
C672 LOAD_EN3_N.n18 VSS 0.33167f
C673 LOAD_EN3_N.n19 VSS 0.46391f
C674 LOAD_EN3_N.n20 VSS 0.14571f
C675 LOAD_EN3_N.n21 VSS 0.15065f
C676 LOAD_EN3_N.n22 VSS 0.15065f
C677 LOAD_EN3_N.n23 VSS 0.15065f
C678 LOAD_EN3_N.n24 VSS 0.14571f
C679 LOAD_EN3_N.n25 VSS 0.33167f
C680 LOAD_EN3_N.n26 VSS 0.45426f
C681 LOAD_EN3_N.n27 VSS 0.2071f
C682 LOAD_EN3_N.n28 VSS 0.03786f
C683 LOAD_EN3_N.n29 VSS 0.03786f
C684 LOAD_EN3_N.n30 VSS 0.03786f
C685 LOAD_EN3_N.n31 VSS 0.02604f
C686 LOAD_EN3_N.n32 VSS 0.11022f
C687 LOAD_EN3_N.n33 VSS 0.14515f
C688 LOAD_EN3_N.n34 VSS 0.15065f
C689 LOAD_EN3_N.n35 VSS 0.15065f
C690 LOAD_EN3_N.n36 VSS 0.15065f
C691 LOAD_EN3_N.n37 VSS 0.14515f
C692 LOAD_EN3_N.n38 VSS 0.11022f
C693 LOAD_EN3_N.n39 VSS 0.03786f
C694 LOAD_EN3_N.n40 VSS 0.03786f
C695 LOAD_EN3_N.n41 VSS 0.03786f
C696 LOAD_EN3_N.n42 VSS 1.5344f
C697 LOAD_EN3_N.n43 VSS 0.14571f
C698 LOAD_EN3_N.n44 VSS 0.15065f
C699 LOAD_EN3_N.n45 VSS 0.15065f
C700 LOAD_EN3_N.n46 VSS 0.15065f
C701 LOAD_EN3_N.n47 VSS 0.14571f
C702 LOAD_EN3_N.n48 VSS 0.33761f
C703 LOAD_EN3_N.n49 VSS 0.14571f
C704 LOAD_EN3_N.n50 VSS 0.15065f
C705 LOAD_EN3_N.n51 VSS 0.15065f
C706 LOAD_EN3_N.n52 VSS 0.15065f
C707 LOAD_EN3_N.n53 VSS 0.14571f
C708 LOAD_EN3_N.n54 VSS 0.33167f
C709 LOAD_EN3_N.n55 VSS 0.75926f
C710 LOAD_EN3_N.n56 VSS 0.14571f
C711 LOAD_EN3_N.n57 VSS 0.15065f
C712 LOAD_EN3_N.n58 VSS 0.15065f
C713 LOAD_EN3_N.n59 VSS 0.15065f
C714 LOAD_EN3_N.n60 VSS 0.14571f
C715 LOAD_EN3_N.n61 VSS 0.33167f
C716 LOAD_EN3_N.n62 VSS 0.46391f
C717 LOAD_EN3_N.n63 VSS 0.14571f
C718 LOAD_EN3_N.n64 VSS 0.15065f
C719 LOAD_EN3_N.n65 VSS 0.15065f
C720 LOAD_EN3_N.n66 VSS 0.15065f
C721 LOAD_EN3_N.n67 VSS 0.14571f
C722 LOAD_EN3_N.n68 VSS 0.33167f
C723 LOAD_EN3_N.n69 VSS 0.45426f
C724 LOAD_EN3_N.n70 VSS 0.2071f
C725 LOAD_EN3_N.n71 VSS 0.03786f
C726 LOAD_EN3_N.n72 VSS 0.03786f
C727 LOAD_EN3_N.n73 VSS 0.02604f
C728 LOAD_EN3_N.n74 VSS 0.11022f
C729 LOAD_EN3_N.n75 VSS 0.14515f
C730 LOAD_EN3_N.n76 VSS 0.15065f
C731 LOAD_EN3_N.n77 VSS 0.15065f
C732 LOAD_EN3_N.n78 VSS 0.15065f
C733 LOAD_EN3_N.n79 VSS 0.14515f
C734 LOAD_EN3_N.n80 VSS 0.11022f
C735 LOAD_EN3_N.n81 VSS 0.03786f
C736 LOAD_EN3_N.n82 VSS 0.03786f
C737 LOAD_EN3_N.n83 VSS 0.03786f
C738 LOAD_EN3_N.n84 VSS 0.03786f
C739 LOAD_EN3_N.n85 VSS 0.18229f
C740 LOAD_EN2_N.n0 VSS 0.13303f
C741 LOAD_EN2_N.n1 VSS 0.03134f
C742 LOAD_EN2_N.n2 VSS 0.17472f
C743 LOAD_EN2_N.n3 VSS 0.18133f
C744 LOAD_EN2_N.n4 VSS 0.18133f
C745 LOAD_EN2_N.n5 VSS 0.18133f
C746 LOAD_EN2_N.n6 VSS 0.17472f
C747 LOAD_EN2_N.n7 VSS 0.13303f
C748 LOAD_EN2_N.n8 VSS 0.27333f
C749 LOAD_EN2_N.n9 VSS 0.13303f
C750 LOAD_EN2_N.n10 VSS 0.17472f
C751 LOAD_EN2_N.n11 VSS 0.17472f
C752 LOAD_EN2_N.n12 VSS 0.18133f
C753 LOAD_EN2_N.n13 VSS 0.18133f
C754 LOAD_EN2_N.n14 VSS 0.18133f
C755 LOAD_EN2_N.n15 VSS 0.03134f
C756 LOAD_EN2_N.n16 VSS 0.13303f
C757 LOAD_EN2_N.n17 VSS 0.71601f
C758 LOAD_EN1_N.n0 VSS 0.14638f
C759 LOAD_EN1_N.n1 VSS 0.19225f
C760 LOAD_EN1_N.n2 VSS 0.19953f
C761 LOAD_EN1_N.n3 VSS 0.19225f
C762 LOAD_EN1_N.n4 VSS 0.19953f
C763 LOAD_EN1_N.n5 VSS 0.19953f
C764 LOAD_EN1_N.n6 VSS 0.03449f
C765 LOAD_EN1_N.n7 VSS 0.14639f
C766 LOAD_EN1_N.n8 VSS 0.74603f
C767 LOAD_EN1_N.n9 VSS 0.14639f
C768 LOAD_EN1_N.n10 VSS 0.19225f
C769 LOAD_EN1_N.n11 VSS 0.19225f
C770 LOAD_EN1_N.n12 VSS 0.19953f
C771 LOAD_EN1_N.n13 VSS 0.19953f
C772 LOAD_EN1_N.n14 VSS 0.19953f
C773 LOAD_EN1_N.n15 VSS 0.03449f
C774 LOAD_EN1_N.n16 VSS 0.14638f
C775 LOAD_EN1_N.n17 VSS 0.15227f
C776 LOAD_EN0_N.n0 VSS 0.12955f
C777 LOAD_EN0_N.n1 VSS 0.03044f
C778 LOAD_EN0_N.n2 VSS 0.1697f
C779 LOAD_EN0_N.n3 VSS 0.17613f
C780 LOAD_EN0_N.n4 VSS 0.17613f
C781 LOAD_EN0_N.n5 VSS 0.17613f
C782 LOAD_EN0_N.n6 VSS 0.1697f
C783 LOAD_EN0_N.n7 VSS 0.12886f
C784 LOAD_EN0_N.n8 VSS 0.38697f
C785 LOAD_EN0_N.n9 VSS 0.12955f
C786 LOAD_EN0_N.n10 VSS 0.1697f
C787 LOAD_EN0_N.n11 VSS 0.1697f
C788 LOAD_EN0_N.n12 VSS 0.17613f
C789 LOAD_EN0_N.n13 VSS 0.17613f
C790 LOAD_EN0_N.n14 VSS 0.17613f
C791 LOAD_EN0_N.n15 VSS 0.03044f
C792 LOAD_EN0_N.n16 VSS 0.12886f
C793 LOAD_EN0_N.n17 VSS 0.35528f
C794 OUTP.t6 VSS 0.12149f
C795 OUTP.t18 VSS 0.10287f
C796 OUTP.n0 VSS 1.5566f
C797 OUTP.t11 VSS 0.10287f
C798 OUTP.n1 VSS 0.95873f
C799 OUTP.t5 VSS 0.10287f
C800 OUTP.n2 VSS 0.95873f
C801 OUTP.t9 VSS 0.10287f
C802 OUTP.n3 VSS 0.95873f
C803 OUTP.t8 VSS 0.10287f
C804 OUTP.n4 VSS 0.95873f
C805 OUTP.t7 VSS 0.10287f
C806 OUTP.n5 VSS 0.95873f
C807 OUTP.t10 VSS 0.10287f
C808 OUTP.n6 VSS 0.89713f
C809 OUTP.t12 VSS 0.10287f
C810 OUTP.n7 VSS 1.03402f
C811 OUTP.t17 VSS 1.60156f
C812 OUTP.n8 VSS 0.22348f
C813 OUTP.t13 VSS 0.43391f
C814 OUTP.t15 VSS 0.43301f
C815 OUTP.n9 VSS 1.06439f
C816 OUTP.t14 VSS 0.43301f
C817 OUTP.t16 VSS 0.43301f
C818 OUTP.n10 VSS 1.06439f
C819 OUTP.n11 VSS 0.22669f
C820 OUTP.n12 VSS 0.19028f
C821 OUTP.n13 VSS 0.62126f
C822 OUTP.t4 VSS 0.43522f
C823 OUTP.t3 VSS 0.43432f
C824 OUTP.n14 VSS 1.06679f
C825 OUTP.n15 VSS 0.21933f
C826 OUTP.t2 VSS 0.43432f
C827 OUTP.t1 VSS 0.43432f
C828 OUTP.n16 VSS 1.06439f
C829 OUTP.n17 VSS 0.22669f
C830 OUTP.t0 VSS 1.60037f
C831 OUTP.n18 VSS 0.20269f
C832 OUTP.n19 VSS 0.54464f
C833 OUTP.n20 VSS 0.46773f
C834 OUTN.t12 VSS 0.12253f
C835 OUTN.t13 VSS 0.10375f
C836 OUTN.n0 VSS 1.56995f
C837 OUTN.t5 VSS 0.10375f
C838 OUTN.n1 VSS 0.96695f
C839 OUTN.t6 VSS 0.10375f
C840 OUTN.n2 VSS 0.96695f
C841 OUTN.t7 VSS 0.10375f
C842 OUTN.n3 VSS 0.96695f
C843 OUTN.t8 VSS 0.10375f
C844 OUTN.n4 VSS 0.96695f
C845 OUTN.t9 VSS 0.10375f
C846 OUTN.n5 VSS 0.96695f
C847 OUTN.t10 VSS 0.10375f
C848 OUTN.n6 VSS 0.90482f
C849 OUTN.t11 VSS 0.10375f
C850 OUTN.n7 VSS 1.04289f
C851 OUTN.t4 VSS 1.61629f
C852 OUTN.n8 VSS 0.2254f
C853 OUTN.t2 VSS 0.43863f
C854 OUTN.t1 VSS 0.43772f
C855 OUTN.n9 VSS 1.07352f
C856 OUTN.t0 VSS 0.43772f
C857 OUTN.t3 VSS 0.43772f
C858 OUTN.n10 VSS 1.07352f
C859 OUTN.n11 VSS 0.22863f
C860 OUTN.n12 VSS 0.19191f
C861 OUTN.n13 VSS 0.51153f
C862 OUTN.t18 VSS 0.43653f
C863 OUTN.t17 VSS 0.43563f
C864 OUTN.n14 VSS 1.07594f
C865 OUTN.n15 VSS 0.22121f
C866 OUTN.t16 VSS 0.43563f
C867 OUTN.t15 VSS 0.43563f
C868 OUTN.n16 VSS 1.07352f
C869 OUTN.n17 VSS 0.22863f
C870 OUTN.t14 VSS 1.61168f
C871 OUTN.n18 VSS 0.20443f
C872 OUTN.n19 VSS 0.66437f
C873 OUTN.n20 VSS 0.47174f
C874 EVEN_P.n0 VSS 0.03758f
C875 EVEN_P.n1 VSS 0.10938f
C876 EVEN_P.n2 VSS 0.10788f
C877 EVEN_P.n3 VSS 0.1114f
C878 EVEN_P.n4 VSS 0.1114f
C879 EVEN_P.n5 VSS 0.1114f
C880 EVEN_P.n6 VSS 0.10822f
C881 EVEN_P.n7 VSS 0.02899f
C882 ODD_P.n0 VSS 0.03794f
C883 ODD_P.n1 VSS 0.11042f
C884 ODD_P.n2 VSS 0.10892f
C885 ODD_P.n3 VSS 0.11247f
C886 ODD_P.n4 VSS 0.11247f
C887 ODD_P.n5 VSS 0.11247f
C888 ODD_P.n6 VSS 0.10926f
C889 ODD_P.n7 VSS 0.02927f
C890 ODD_N.n0 VSS 0.03817f
C891 ODD_N.n1 VSS 0.11111f
C892 ODD_N.n2 VSS 0.10959f
C893 ODD_N.n3 VSS 0.11317f
C894 ODD_N.n4 VSS 0.11317f
C895 ODD_N.n5 VSS 0.11317f
C896 ODD_N.n6 VSS 0.10994f
C897 ODD_N.n7 VSS 0.02945f
C898 EVEN_N.n0 VSS 0.0376f
C899 EVEN_N.n1 VSS 0.10944f
C900 EVEN_N.n2 VSS 0.10795f
C901 EVEN_N.n3 VSS 0.11147f
C902 EVEN_N.n4 VSS 0.11147f
C903 EVEN_N.n5 VSS 0.11147f
C904 EVEN_N.n6 VSS 0.10829f
C905 EVEN_N.n7 VSS 0.02901f
C906 CLK_P.n0 VSS 0.03725f
C907 CLK_P.n1 VSS 0.10841f
C908 CLK_P.n2 VSS 0.10693f
C909 CLK_P.n3 VSS 0.11042f
C910 CLK_P.n4 VSS 0.11042f
C911 CLK_P.n5 VSS 0.11042f
C912 CLK_P.n6 VSS 0.10726f
C913 CLK_P.n7 VSS 0.02873f
C914 CLK_N.n0 VSS 0.03743f
C915 CLK_N.n1 VSS 0.10894f
C916 CLK_N.n2 VSS 0.10745f
C917 CLK_N.n3 VSS 0.11096f
C918 CLK_N.n4 VSS 0.11096f
C919 CLK_N.n5 VSS 0.11096f
C920 CLK_N.n6 VSS 0.10779f
C921 CLK_N.n7 VSS 0.02887f
C922 VBIAS.n0 VSS 0.02019f
C923 VBIAS.n1 VSS 0.02019f
C924 VBIAS.n2 VSS 0.02019f
C925 VBIAS.n3 VSS 0.02019f
C926 VBIAS.n4 VSS 0.05876f
C927 VBIAS.n5 VSS 0.05821f
C928 VBIAS.n6 VSS 0.05985f
C929 VBIAS.n7 VSS 0.05985f
C930 VBIAS.n8 VSS 0.05985f
C931 VBIAS.n9 VSS 0.05985f
C932 VBIAS.n10 VSS 0.05985f
C933 VBIAS.n11 VSS 0.05985f
C934 VBIAS.n12 VSS 0.05985f
C935 VBIAS.n13 VSS 0.02019f
C936 VBIAS.n14 VSS 0.05985f
C937 VBIAS.n15 VSS 0.05985f
C938 VBIAS.n16 VSS 0.05821f
C939 VBIAS.n17 VSS 0.05876f
C940 VBIAS.n18 VSS 0.02019f
C941 VBIAS.n19 VSS 0.05985f
C942 VBIAS.n20 VSS 0.05985f
C943 VBIAS.n21 VSS 0.05985f
C944 VBIAS.n22 VSS 0.02019f
.ends
