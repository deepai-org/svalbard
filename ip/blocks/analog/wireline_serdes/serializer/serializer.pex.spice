* PEX produced on Thu Aug 20 02:31:02 AM CEST 2026 using /foss/tools/sak/sak-pex.sh with m=3 and s=1 (extresist threshold=0 mOhm, minres=1 mOhm, mindelay=0 ps)
* NGSPICE file created from cml_serializer_2to1_pex.ext - technology: gf180mcuD

.subckt cml_serializer_2to1_pex EVEN_P EVEN_N ODD_P ODD_N CLK_P CLK_N VBIAS VDD VSS
+ SER_P SER_N
X0 a_n1652_n2400.t3 VBIAS.t0 VSS.t15 VSS.t14 nfet_03v3 ad=4.4p pd=20.88u as=2.6p ps=10.52u w=10u l=0.28u
X1 a_n1652_n2400.t7 CLK_P.t1 a_n2452_200.t4 VSS.t20 nfet_03v3 ad=2.08p pd=8.52u as=3.52p ps=16.88u w=8u l=0.28u
X2 a_n2452_200.t5 CLK_P.t0 a_n1652_n2400.t6 VSS.t21 nfet_03v3 ad=3.52p pd=16.88u as=2.08p ps=8.52u w=8u l=0.28u
X3 a_n852_200.t5 CLK_N.t0 a_n1652_n2400.t5 VSS.t19 nfet_03v3 ad=3.52p pd=16.88u as=2.08p ps=8.52u w=8u l=0.28u
X4 VSS.t11 VBIAS.t3 a_n1652_n2400.t0 VSS.t10 nfet_03v3 ad=2.6p pd=10.52u as=4.4p ps=20.88u w=10u l=0.28u
X5 SER_N.t3 EVEN_P.t0 a_n2452_200.t3 VSS.t17 nfet_03v3 ad=2.64p pd=12.88u as=1.56p ps=6.52u w=6u l=0.28u
X6 SER_N.t1 ODD_P.t0 a_n852_200.t3 VSS.t7 nfet_03v3 ad=2.64p pd=12.88u as=1.56p ps=6.52u w=6u l=0.28u
X7 a_n852_200.t0 ODD_N.t1 SER_P.t2 VSS.t1 nfet_03v3 ad=1.56p pd=6.52u as=2.64p ps=12.88u w=6u l=0.28u
X8 a_n1652_n2400.t4 CLK_N.t1 a_n852_200.t4 VSS.t18 nfet_03v3 ad=2.08p pd=8.52u as=3.52p ps=16.88u w=8u l=0.28u
X9 VDD.t0 SER_P.t0 VSS.t0 ppolyf_u r_width=2u r_length=7.5u
X10 a_n2452_200.t0 EVEN_N.t1 SER_P.t4 VSS.t3 nfet_03v3 ad=1.56p pd=6.52u as=2.64p ps=12.88u w=6u l=0.28u
X11 VSS.t13 VBIAS.t1 a_n1652_n2400.t2 VSS.t12 nfet_03v3 ad=2.6p pd=10.52u as=2.6p ps=10.52u w=10u l=0.28u
X12 a_n2452_200.t2 EVEN_P.t1 SER_N.t4 VSS.t16 nfet_03v3 ad=1.56p pd=6.52u as=2.64p ps=12.88u w=6u l=0.28u
X13 VDD.t1 SER_N.t0 VSS.t5 ppolyf_u r_width=2u r_length=7.5u
X14 a_n1652_n2400.t1 VBIAS.t2 VSS.t9 VSS.t8 nfet_03v3 ad=2.6p pd=10.52u as=2.6p ps=10.52u w=10u l=0.28u
X15 a_n852_200.t2 ODD_P.t1 SER_N.t2 VSS.t6 nfet_03v3 ad=1.56p pd=6.52u as=2.64p ps=12.88u w=6u l=0.28u
X16 SER_P.t1 ODD_N.t0 a_n852_200.t1 VSS.t2 nfet_03v3 ad=2.64p pd=12.88u as=1.56p ps=6.52u w=6u l=0.28u
X17 SER_P.t3 EVEN_N.t0 a_n2452_200.t1 VSS.t4 nfet_03v3 ad=2.64p pd=12.88u as=1.56p ps=6.52u w=6u l=0.28u
R0 VBIAS.n1 VBIAS.t0 139.702
R1 VBIAS.n2 VBIAS.t1 135.246
R2 VBIAS.n3 VBIAS.t2 135.246
R3 VBIAS.n4 VBIAS.t3 135.246
R4 VBIAS.n3 VBIAS.n0 18.4942
R5 VBIAS.n5 VBIAS.n4 18.4942
R6 VBIAS.n3 VBIAS.n2 11.6805
R7 VBIAS.n4 VBIAS.n3 11.6805
R8 VBIAS.n1 VBIAS.n0 7.17687
R9 VBIAS.n2 VBIAS.n1 4.42851
R10 VBIAS.n5 VBIAS.n0 0.1205
R11 VBIAS VBIAS.n5 0.053
R12 CLK_N.n0 CLK_N.t0 113.632
R13 CLK_N.n0 CLK_N.t1 113.603
R14 CLK_N CLK_N.n0 7.08687
R15 CLK_P.n0 CLK_P.t0 113.632
R16 CLK_P.n0 CLK_P.t1 113.603
R17 CLK_P CLK_P.n0 7.08687
R18 EVEN_N.n0 EVEN_N.t0 87.5599
R19 EVEN_N.n0 EVEN_N.t1 87.5312
R20 EVEN_N EVEN_N.n0 7.10487
R21 ODD_N.n0 ODD_N.t0 87.5599
R22 ODD_N.n0 ODD_N.t1 87.5312
R23 ODD_N ODD_N.n0 7.10487
R24 ODD_P.n0 ODD_P.t0 87.5599
R25 ODD_P.n0 ODD_P.t1 87.5312
R26 ODD_P ODD_P.n0 7.10487
R27 EVEN_P.n0 EVEN_P.t0 87.5599
R28 EVEN_P.n0 EVEN_P.t1 87.5312
R29 EVEN_P EVEN_P.n0 7.10487
R30 SER_P SER_P.t0 12.63
R31 SER_P.n1 SER_P.t2 5.96544
R32 SER_P.n0 SER_P.t3 5.96544
R33 SER_P.n1 SER_P.t1 5.9622
R34 SER_P.n0 SER_P.t4 5.9622
R35 SER_P.n2 SER_P.n0 2.56391
R36 SER_P.n2 SER_P.n1 2.56391
R37 SER_P SER_P.n2 0.5805
R38 SER_N SER_N.t0 12.63
R39 SER_N.n1 SER_N.t4 5.96544
R40 SER_N.n0 SER_N.t1 5.96544
R41 SER_N.n1 SER_N.t3 5.9622
R42 SER_N.n0 SER_N.t2 5.9622
R43 SER_N.n2 SER_N.n0 2.56391
R44 SER_N.n2 SER_N.n1 2.56391
R45 SER_N SER_N.n2 0.5805
R46 VDD VDD.t0 21.71
R47 VDD VDD.t1 21.6211
R48 VSS.n95 VSS.n4 354.546
R49 VSS.n50 VSS.n18 354.546
R50 VSS.n95 VSS.n94 153.637
R51 VSS.t16 VSS.n4 153.637
R52 VSS.n50 VSS.t4 153.637
R53 VSS.n67 VSS.n18 153.637
R54 VSS.n40 VSS.t17 107.546
R55 VSS.n39 VSS.t6 107.546
R56 VSS.n48 VSS.t2 107.546
R57 VSS.t3 VSS.n49 107.546
R58 VSS.n38 VSS.t10 106.365
R59 VSS.n47 VSS.t14 106.365
R60 VSS.n39 VSS.t21 81.546
R61 VSS.n48 VSS.t18 81.546
R62 VSS.n96 VSS.n2 52.5005
R63 VSS.n30 VSS.n2 52.5005
R64 VSS.n37 VSS.n30 52.5005
R65 VSS.n37 VSS.n26 52.5005
R66 VSS.n32 VSS.n26 52.5005
R67 VSS.n32 VSS.n24 52.5005
R68 VSS.n24 VSS.n14 52.5005
R69 VSS.n81 VSS.n80 52.5005
R70 VSS.n85 VSS.n84 52.5005
R71 VSS.n89 VSS.n88 52.5005
R72 VSS.n93 VSS.n10 52.5005
R73 VSS.n29 VSS.n5 52.5005
R74 VSS.n42 VSS.n29 52.5005
R75 VSS.n42 VSS.n27 52.5005
R76 VSS.n46 VSS.n27 52.5005
R77 VSS.n46 VSS.n23 52.5005
R78 VSS.n51 VSS.n23 52.5005
R79 VSS.n51 VSS.n21 52.5005
R80 VSS.n54 VSS.n15 52.5005
R81 VSS.n58 VSS.n57 52.5005
R82 VSS.n60 VSS.n19 52.5005
R83 VSS.n20 VSS.n19 52.5005
R84 VSS.n96 VSS.n3 50.7505
R85 VSS.n69 VSS.n14 50.7505
R86 VSS.t17 VSS.t16 47.2732
R87 VSS.t6 VSS.t7 47.2732
R88 VSS.t10 VSS.t8 47.2732
R89 VSS.t8 VSS.t12 47.2732
R90 VSS.t12 VSS.t14 47.2732
R91 VSS.t2 VSS.t1 47.2732
R92 VSS.t4 VSS.t3 47.2732
R93 VSS.n41 VSS.n40 46.0914
R94 VSS.n49 VSS.n25 46.0914
R95 VSS.n93 VSS.n5 42.0005
R96 VSS.n65 VSS.n21 42.0005
R97 VSS.n41 VSS.t20 35.455
R98 VSS.t7 VSS.n38 35.455
R99 VSS.t1 VSS.n47 35.455
R100 VSS.t19 VSS.n25 35.455
R101 VSS.t5 VSS.t20 23.6369
R102 VSS.t21 VSS.t5 23.6369
R103 VSS.t18 VSS.t0 23.6369
R104 VSS.t0 VSS.t19 23.6369
R105 VSS VSS.n98 19.0449
R106 VSS.n78 VSS.n77 11.6887
R107 VSS.n72 VSS.n71 11.6887
R108 VSS.n74 VSS.n73 6.29333
R109 VSS.n76 VSS.n75 6.29333
R110 VSS.n94 VSS.n93 5.2005
R111 VSS.n93 VSS.n92 5.2005
R112 VSS.n91 VSS.n10 5.2005
R113 VSS.n90 VSS.n89 5.2005
R114 VSS.n88 VSS.n87 5.2005
R115 VSS.n86 VSS.n85 5.2005
R116 VSS.n84 VSS.n83 5.2005
R117 VSS.n82 VSS.n81 5.2005
R118 VSS.n80 VSS.n79 5.2005
R119 VSS.n3 VSS.n0 5.2005
R120 VSS.n95 VSS.n5 5.2005
R121 VSS.n11 VSS.n5 5.2005
R122 VSS.n29 VSS.n4 5.2005
R123 VSS.n29 VSS.n28 5.2005
R124 VSS.n42 VSS.n41 5.2005
R125 VSS.n43 VSS.n42 5.2005
R126 VSS.n38 VSS.n27 5.2005
R127 VSS.n44 VSS.n27 5.2005
R128 VSS.n47 VSS.n46 5.2005
R129 VSS.n46 VSS.n45 5.2005
R130 VSS.n25 VSS.n23 5.2005
R131 VSS.n23 VSS.n22 5.2005
R132 VSS.n51 VSS.n50 5.2005
R133 VSS.n52 VSS.n51 5.2005
R134 VSS.n21 VSS.n18 5.2005
R135 VSS.n53 VSS.n21 5.2005
R136 VSS.n70 VSS.n69 5.2005
R137 VSS.n15 VSS.n12 5.2005
R138 VSS.n55 VSS.n54 5.2005
R139 VSS.n57 VSS.n56 5.2005
R140 VSS.n59 VSS.n58 5.2005
R141 VSS.n61 VSS.n60 5.2005
R142 VSS.n67 VSS.n19 5.2005
R143 VSS.n62 VSS.n19 5.2005
R144 VSS.n63 VSS.n20 5.2005
R145 VSS.n65 VSS.n64 5.2005
R146 VSS.n18 VSS.n14 5.2005
R147 VSS.n14 VSS.n13 5.2005
R148 VSS.n50 VSS.n24 5.2005
R149 VSS.n31 VSS.n24 5.2005
R150 VSS.n32 VSS.n25 5.2005
R151 VSS.n33 VSS.n32 5.2005
R152 VSS.n47 VSS.n26 5.2005
R153 VSS.n34 VSS.n26 5.2005
R154 VSS.n38 VSS.n37 5.2005
R155 VSS.n37 VSS.n36 5.2005
R156 VSS.n41 VSS.n30 5.2005
R157 VSS.n35 VSS.n30 5.2005
R158 VSS.n4 VSS.n2 5.2005
R159 VSS.n2 VSS.n1 5.2005
R160 VSS.n96 VSS.n95 5.2005
R161 VSS.n97 VSS.n96 5.2005
R162 VSS.n77 VSS.n76 4.5005
R163 VSS.n74 VSS.n72 4.5005
R164 VSS.n10 VSS.n9 4.34122
R165 VSS.n88 VSS.n8 4.34122
R166 VSS.n84 VSS.n7 4.34122
R167 VSS.n80 VSS.n6 4.34122
R168 VSS.n69 VSS.n68 4.34122
R169 VSS.n54 VSS.n17 4.34122
R170 VSS.n58 VSS.n16 4.34122
R171 VSS.n66 VSS.n20 4.34122
R172 VSS.n6 VSS.n3 4.34122
R173 VSS.n81 VSS.n7 4.34122
R174 VSS.n85 VSS.n8 4.34122
R175 VSS.n89 VSS.n9 4.34122
R176 VSS.n68 VSS.n15 4.34122
R177 VSS.n57 VSS.n17 4.34122
R178 VSS.n60 VSS.n16 4.34122
R179 VSS.n66 VSS.n65 4.34122
R180 VSS.n49 VSS.n48 3.58947
R181 VSS.n40 VSS.n39 3.58947
R182 VSS.n82 VSS.n79 0.6755
R183 VSS.n83 VSS.n82 0.6755
R184 VSS.n86 VSS.n83 0.6755
R185 VSS.n87 VSS.n86 0.6755
R186 VSS.n90 VSS.n87 0.6755
R187 VSS.n91 VSS.n90 0.6755
R188 VSS.n92 VSS.n91 0.6755
R189 VSS.n28 VSS.n11 0.6755
R190 VSS.n43 VSS.n28 0.6755
R191 VSS.n44 VSS.n43 0.6755
R192 VSS.n45 VSS.n44 0.6755
R193 VSS.n45 VSS.n22 0.6755
R194 VSS.n52 VSS.n22 0.6755
R195 VSS.n53 VSS.n52 0.6755
R196 VSS.n55 VSS.n12 0.6755
R197 VSS.n56 VSS.n55 0.6755
R198 VSS.n59 VSS.n56 0.6755
R199 VSS.n61 VSS.n59 0.6755
R200 VSS.n62 VSS.n61 0.6755
R201 VSS.n63 VSS.n62 0.6755
R202 VSS.n64 VSS.n63 0.6755
R203 VSS.n97 VSS.n1 0.6755
R204 VSS.n35 VSS.n1 0.6755
R205 VSS.n36 VSS.n35 0.6755
R206 VSS.n36 VSS.n34 0.6755
R207 VSS.n34 VSS.n33 0.6755
R208 VSS.n33 VSS.n31 0.6755
R209 VSS.n31 VSS.n13 0.6755
R210 VSS.n70 VSS.n13 0.653
R211 VSS.n79 VSS.n78 0.563
R212 VSS.n71 VSS.n12 0.563
R213 VSS.n92 VSS.n11 0.5405
R214 VSS.n64 VSS.n53 0.5405
R215 VSS.n94 VSS.n9 0.430889
R216 VSS.n94 VSS.n8 0.430889
R217 VSS.n94 VSS.n7 0.430889
R218 VSS.n94 VSS.n6 0.430889
R219 VSS.n68 VSS.n67 0.430889
R220 VSS.n67 VSS.n17 0.430889
R221 VSS.n67 VSS.n16 0.430889
R222 VSS.n67 VSS.n66 0.430889
R223 VSS.n98 VSS.n97 0.37175
R224 VSS.n98 VSS.n0 0.28175
R225 VSS.n77 VSS.n72 0.189974
R226 VSS.n76 VSS.n74 0.189974
R227 VSS.n73 VSS.t13 0.1643
R228 VSS.n73 VSS.t15 0.1643
R229 VSS.n75 VSS.t11 0.1643
R230 VSS.n75 VSS.t9 0.1643
R231 VSS.n78 VSS.n0 0.113
R232 VSS.n71 VSS.n70 0.113
R233 a_n1652_n2400.n5 a_n1652_n2400.n3 11.0732
R234 a_n1652_n2400.n5 a_n1652_n2400.n4 11.0732
R235 a_n1652_n2400.t3 a_n1652_n2400.n7 6.55182
R236 a_n1652_n2400.n2 a_n1652_n2400.t0 6.45713
R237 a_n1652_n2400.n1 a_n1652_n2400.n0 6.29333
R238 a_n1652_n2400.n6 a_n1652_n2400.n2 4.63668
R239 a_n1652_n2400.n7 a_n1652_n2400.n6 2.23814
R240 a_n1652_n2400.n6 a_n1652_n2400.n5 0.3755
R241 a_n1652_n2400.n3 a_n1652_n2400.t7 0.20525
R242 a_n1652_n2400.n3 a_n1652_n2400.t6 0.20525
R243 a_n1652_n2400.n4 a_n1652_n2400.t4 0.20525
R244 a_n1652_n2400.n4 a_n1652_n2400.t5 0.20525
R245 a_n1652_n2400.n2 a_n1652_n2400.n1 0.189974
R246 a_n1652_n2400.n0 a_n1652_n2400.t1 0.1643
R247 a_n1652_n2400.n0 a_n1652_n2400.t2 0.1643
R248 a_n1652_n2400.n7 a_n1652_n2400.n1 0.0924286
R249 a_n852_200.n2 a_n852_200.n0 15.5136
R250 a_n852_200.n2 a_n852_200.n1 14.5662
R251 a_n852_200.n3 a_n852_200.n2 8.12801
R252 a_n852_200.n3 a_n852_200.t5 5.9772
R253 a_n852_200.t4 a_n852_200.n3 5.9772
R254 a_n852_200.n0 a_n852_200.t3 0.2735
R255 a_n852_200.n0 a_n852_200.t2 0.2735
R256 a_n852_200.n1 a_n852_200.t1 0.2735
R257 a_n852_200.n1 a_n852_200.t0 0.2735
R258 a_n2452_200.n2 a_n2452_200.n0 20.1188
R259 a_n2452_200.n2 a_n2452_200.n1 19.2767
R260 a_n2452_200.n3 a_n2452_200.n2 11.653
R261 a_n2452_200.n3 a_n2452_200.t5 5.9772
R262 a_n2452_200.t4 a_n2452_200.n3 5.9772
R263 a_n2452_200.n1 a_n2452_200.t3 0.2735
R264 a_n2452_200.n1 a_n2452_200.t2 0.2735
R265 a_n2452_200.n0 a_n2452_200.t1 0.2735
R266 a_n2452_200.n0 a_n2452_200.t0 0.2735
C0 SER_P EVEN_N 0.16205f
C1 SER_P ODD_N 0.16205f
C2 ODD_P SER_N 0.16205f
C3 VDD SER_N 0.02514f
C4 EVEN_P SER_N 0.16205f
C5 SER_P SER_N 0.05732f
C6 SER_P VDD 0.02514f
C7 VBIAS VSS 1.54655f
C8 CLK_N VSS 0.60141f
C9 CLK_P VSS 0.60184f
C10 EVEN_N VSS 0.60116f
C11 ODD_N VSS 0.59805f
C12 ODD_P VSS 0.59716f
C13 EVEN_P VSS 0.60092f
C14 SER_P VSS 3.70947f
C15 SER_N VSS 3.70495f
C16 VDD VSS 4.37299f
C17 a_n2452_200.t5 VSS 0.59793f
C18 a_n2452_200.t1 VSS 0.13087f
C19 a_n2452_200.t0 VSS 0.13085f
C20 a_n2452_200.n0 VSS 0.47133f
C21 a_n2452_200.t3 VSS 0.13072f
C22 a_n2452_200.t2 VSS 0.1307f
C23 a_n2452_200.n1 VSS 0.42636f
C24 a_n2452_200.n2 VSS 2.7926f
C25 a_n2452_200.n3 VSS 0.45378f
C26 a_n2452_200.t4 VSS 0.59792f
C27 a_n852_200.t5 VSS 0.71868f
C28 a_n852_200.t3 VSS 0.15062f
C29 a_n852_200.t2 VSS 0.1506f
C30 a_n852_200.n0 VSS 0.51113f
C31 a_n852_200.t1 VSS 0.15117f
C32 a_n852_200.t0 VSS 0.15116f
C33 a_n852_200.n1 VSS 0.47977f
C34 a_n852_200.n2 VSS 2.1128f
C35 a_n852_200.n3 VSS 0.59568f
C36 a_n852_200.t4 VSS 0.71867f
C37 a_n1652_n2400.t2 VSS 0.12878f
C38 a_n1652_n2400.t1 VSS 0.12878f
C39 a_n1652_n2400.n0 VSS 0.34561f
C40 a_n1652_n2400.n1 VSS 0.11259f
C41 a_n1652_n2400.t0 VSS 0.50087f
C42 a_n1652_n2400.n2 VSS 0.10073f
C43 a_n1652_n2400.t6 VSS 0.13556f
C44 a_n1652_n2400.t7 VSS 0.13555f
C45 a_n1652_n2400.n3 VSS 0.32841f
C46 a_n1652_n2400.t5 VSS 0.13522f
C47 a_n1652_n2400.t4 VSS 0.13521f
C48 a_n1652_n2400.n4 VSS 0.32841f
C49 a_n1652_n2400.n5 VSS 1.04427f
C50 a_n1652_n2400.n6 VSS 0.31199f
C51 a_n1652_n2400.n7 VSS 0.09927f
C52 a_n1652_n2400.t3 VSS 0.50284f
C53 VSS.t15 VSS 0.03524f
C54 VSS.t13 VSS 0.03473f
C55 VSS.t9 VSS 0.03473f
C56 VSS.t11 VSS 0.03473f
C57 SER_N.t0 VSS 0.14224f
C58 SER_N.t2 VSS 0.33802f
C59 SER_N.t1 VSS 0.33813f
C60 SER_N.n0 VSS 0.21561f
C61 SER_N.t4 VSS 0.33642f
C62 SER_N.t3 VSS 0.33634f
C63 SER_N.n1 VSS 0.21561f
C64 SER_N.n2 VSS 0.81743f
C65 SER_P.t0 VSS 0.14344f
C66 SER_P.t4 VSS 0.33889f
C67 SER_P.t3 VSS 0.339f
C68 SER_P.n0 VSS 0.21742f
C69 SER_P.t2 VSS 0.34108f
C70 SER_P.t1 VSS 0.341f
C71 SER_P.n1 VSS 0.21742f
C72 SER_P.n2 VSS 0.8243f
C73 EVEN_P.n0 VSS 0.09929f
C74 ODD_P.n0 VSS 0.10265f
C75 ODD_N.n0 VSS 0.10376f
C76 EVEN_N.n0 VSS 0.09959f
C77 CLK_P.n0 VSS 0.11127f
C78 CLK_N.n0 VSS 0.11063f
C79 VBIAS.n0 VSS 0.05457f
C80 VBIAS.n1 VSS 0.03148f
C81 VBIAS.n2 VSS 0.03336f
C82 VBIAS.n3 VSS 0.03336f
C83 VBIAS.n4 VSS 0.03177f
C84 VBIAS.n5 VSS 0.01446f
.ends
