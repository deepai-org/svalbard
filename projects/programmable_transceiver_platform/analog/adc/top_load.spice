* Small-signal top-plate loading: reset comparator and open sampling gate.
.include /foss/pdks/gf180mcuD/libs.tech/ngspice/design.ngspice
.lib /foss/pdks/gf180mcuD/libs.tech/ngspice/sm141064.ngspice typical
.include /screen/adc/comparator.spice
.include /wifi/rf_if_transmission_gate/rf_if_transmission_gate.spice
.lib /foss/pdks/gf180mcuD/libs.tech/ngspice/sm141064.ngspice mimcap_typical
.temp 27
VU U 0 DC 1 AC 1
XUNIT U 0 cap_mim_1f5_m4m5_noshield c_length=5u c_width=5u
VV VDD 0 3.3
VP HP 0 DC 1.65 AC .5
VN HN 0 DC 1.65 AC .5 180
VIP IP 0 1.65
VIN IN 0 1.65
VS SC 0 0
VSB SCB 0 3.3
VC CLK 0 0
XS IP IN HP HN SC SCB VDD 0 wifi_if_transmission_gate
XC HP HN CLK QP QN VDD 0 pt_adc_comparator
CP QP 0 50f
CN QN 0 50f
.control
set wr_singlescale
set wr_vecnames
ac dec 3 1meg 1g
wrdata /work/load.dat i(VP) i(VN) i(VU)
quit
.endc
.end
