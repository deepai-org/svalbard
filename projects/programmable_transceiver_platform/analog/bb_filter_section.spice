* Two finite-gain transistor stages with crossed resistive negative feedback.
* RFB and C are design parameters, not yet physical programmable banks.
.include /screen/bb_pmos_gain.spice
.subckt pt_bb_filter IP IN OP ON BIAS VDD VSS params: RFB=20k C=20p
RIP IP GP 1k
RIN IN GN 1k
RFP ON GP {RFB}
RFN OP GN {RFB}
XA GP GN MP MN T1 BIAS VDD pt_bb_pmos_gain
XB MP MN OP ON T2 BIAS VDD pt_bb_pmos_gain
RMP MP VSS 1k
RMN MN VSS 1k
ROP OP VSS 1k
RON ON VSS 1k
CMP MP VSS {C}
CMN MN VSS {C}
COP OP VSS {C}
CON ON VSS {C}
.ends pt_bb_filter
