* NGSPICE file created from atb_grp_flat.ext - technology: gf180mcuD

.subckt atb_grp_flat NODE BUS SEL VDD VSS
X0 NNO SD SHON VDD pfet_03v3 ad=0.88p pd=4.88u as=0.88p ps=4.88u w=2u l=0.28u
X1 VSS SD SHON VSS nfet_03v3 ad=0.44p pd=2.88u as=0.44p ps=2.88u w=1u l=0.28u
X2 VSS SEL SA VSS nfet_03v3 ad=0.1848p pd=1.72u as=0.1848p ps=1.72u w=0.42u l=2u
X3 VSS SA SD VSS nfet_03v3 ad=0.1848p pd=1.72u as=0.1848p ps=1.72u w=0.42u l=2u
X4 VDD SD TGONB VDD pfet_03v3 ad=0.44p pd=2.88u as=0.44p ps=2.88u w=1u l=0.28u
X5 VDD SEL TGONB VDD pfet_03v3 ad=0.44p pd=2.88u as=0.44p ps=2.88u w=1u l=0.28u
X6 VDD SEL NNO VDD pfet_03v3 ad=0.88p pd=4.88u as=0.88p ps=4.88u w=2u l=0.28u
X7 VSS SEL SHON VSS nfet_03v3 ad=0.44p pd=2.88u as=0.44p ps=2.88u w=1u l=0.28u
X8 VDD SEL SA VDD pfet_03v3 ad=0.3696p pd=2.56u as=0.3696p ps=2.56u w=0.84u l=2u
X9 VDD SA SD VDD pfet_03v3 ad=0.3696p pd=2.56u as=0.3696p ps=2.56u w=0.84u l=2u
X10 VDD TGONB TGON VDD pfet_03v3 ad=0.88p pd=4.88u as=0.88p ps=4.88u w=2u l=0.28u
X11 MID TGON NODE VSS nfet_03v3 ad=3.52p pd=16.88u as=3.52p ps=16.88u w=8u l=0.28u
X12 VSS TGONB TGON VSS nfet_03v3 ad=0.44p pd=2.88u as=0.44p ps=2.88u w=1u l=0.28u
X13 VSS SD NNA VSS nfet_03v3 ad=0.44p pd=2.88u as=0.44p ps=2.88u w=1u l=0.28u
X14 BUS TGONB MID VDD pfet_03v3 ad=7.04p pd=32.88u as=7.04p ps=32.88u w=16u l=0.28u
X15 MID TGONB NODE VDD pfet_03v3 ad=7.04p pd=32.88u as=7.04p ps=32.88u w=16u l=0.28u
X16 BUS TGON MID VSS nfet_03v3 ad=3.52p pd=16.88u as=3.52p ps=16.88u w=8u l=0.28u
X17 VSS SHON MID VSS nfet_03v3 ad=0.88p pd=4.88u as=0.88p ps=4.88u w=2u l=0.28u
X18 VSS VDD SEL VSS nfet_03v3 ad=0.1848p pd=1.72u as=0.1848p ps=1.72u w=0.42u l=20u
X19 NNA SEL TGONB VSS nfet_03v3 ad=0.44p pd=2.88u as=0.44p ps=2.88u w=1u l=0.28u
C0 SEL NNA 0.07594f
C1 MID NODE 4.00253f
C2 MID NNO 0.17012f
C3 MID TGONB 5.9203f
C4 NNA TGON 0.03085f
C5 SD SA 8.20165f
C6 SEL SA 7.14296f
C7 BUS SA 0.1228f
C8 TGON SA 0.30788f
C9 SEL SD 0.5037f
C10 VDD NODE 0.80579f
C11 BUS SD 0.12807f
C12 VDD NNO 1.8945f
C13 SHON SA 0.1104f
C14 VDD TGONB 5.99553f
C15 SEL BUS 0.12223f
C16 SD TGON 3.32734f
C17 SEL TGON 0.45504f
C18 SHON SD 2.55975f
C19 NODE TGONB 1.422f
C20 BUS TGON 0.24764f
C21 NNO TGONB 0.50502f
C22 SEL SHON 0.83439f
C23 MID SA 4.7832f
C24 SHON BUS 6.83333f
C25 SHON TGON 1.3922f
C26 NNA VDD 0.01302f
C27 MID SD 0.36231f
C28 SEL MID 8.69225f
C29 MID BUS 4.10534f
C30 NNA TGONB 0.81252f
C31 VDD SA 6.39516f
C32 MID TGON 10.1809f
C33 SHON MID 1.05026f
C34 SD VDD 8.15817f
C35 SA NNO 0.1191f
C36 SA TGONB 0.34607f
C37 SEL VDD 18.6168f
C38 BUS VDD 1.38159f
C39 SD NNO 0.2456f
C40 TGON VDD 1.81424f
C41 SD TGONB 6.67012f
C42 SEL NNO 1.24803f
C43 SEL TGONB 2.1755f
C44 BUS NNO 0.09914f
C45 SHON VDD 0.51763f
C46 BUS TGONB 0.65189f
C47 TGON NODE 0.121f
C48 TGON NNO 0.66161f
C49 TGON TGONB 2.09192f
C50 SHON NNO 1.23708f
C51 SHON TGONB 3.53792f
C52 MID VDD 3.04902f
C53 SD NNA 1.1822f
C54 BUS VSS 5.69157f
C55 SEL VSS 9.67621f
C56 NODE VSS 0.90236f
C57 VDD VSS 0.16064p
C58 NNA VSS 1.65383f ; **FLOATING
C59 SHON VSS 5.47208f ; **FLOATING
C60 NNO VSS 0.87953f ; **FLOATING
C61 SA VSS 8.30591f ; **FLOATING
C62 TGON VSS 11.8339f ; **FLOATING
C63 SD VSS 6.77142f ; **FLOATING
C64 MID VSS 6.60331f ; **FLOATING
C65 TGONB VSS 6.87783f ; **FLOATING
.ends
