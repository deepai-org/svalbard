* NGSPICE file created from atb_pad_flat.ext - technology: gf180mcuD

.subckt atb_pad_flat PAD BUS SEL VDD VSS
X0 VDD SEL NNO VDD pfet_03v3 ad=0.88p pd=4.88u as=0.88p ps=4.88u w=2u l=0.28u
X1 VDD TGONB TGON VDD pfet_03v3 ad=0.88p pd=4.88u as=0.88p ps=4.88u w=2u l=0.28u
X2 NNA SEL TGONB VSS nfet_03v3 ad=0.44p pd=2.88u as=0.44p ps=2.88u w=1u l=0.28u
X3 VDD SD TGONB VDD pfet_03v3 ad=0.44p pd=2.88u as=0.44p ps=2.88u w=1u l=0.28u
X4 VDD SA SD VDD pfet_03v3 ad=0.3696p pd=2.56u as=0.3696p ps=2.56u w=0.84u l=2u
X5 VSS SD SHON VSS nfet_03v3 ad=0.44p pd=2.88u as=0.44p ps=2.88u w=1u l=0.28u
X6 VSS SHON BUS VSS nfet_03v3 ad=0.88p pd=4.88u as=0.88p ps=4.88u w=2u l=0.28u
X7 VSS VDD SEL VSS nfet_03v3 ad=0.1848p pd=1.72u as=0.1848p ps=1.72u w=0.42u l=20u
X8 BUS GP PAD VMAX pfet_03v3 ad=7.04p pd=32.88u as=7.04p ps=32.88u w=16u l=0.28u
X9 VMAX TGON GP VMAX pfet_03v3 ad=0.44p pd=2.88u as=0.44p ps=2.88u w=1u l=0.28u
X10 VDD SEL SA VDD pfet_03v3 ad=0.3696p pd=2.56u as=0.3696p ps=2.56u w=0.84u l=2u
X11 VSS SEL SA VSS nfet_03v3 ad=0.1848p pd=1.72u as=0.1848p ps=1.72u w=0.42u l=2u
X12 VSS SA SD VSS nfet_03v3 ad=0.1848p pd=1.72u as=0.1848p ps=1.72u w=0.42u l=2u
X13 VSS SEL SHON VSS nfet_03v3 ad=0.44p pd=2.88u as=0.44p ps=2.88u w=1u l=0.28u
X14 PAD VDD VMAX VMAX pfet_03v3 ad=0.88p pd=4.88u as=0.88p ps=4.88u w=2u l=0.28u
X15 VDD SEL TGONB VDD pfet_03v3 ad=0.44p pd=2.88u as=0.44p ps=2.88u w=1u l=0.28u
X16 BUS TGON PAD VSS nfet_03v3 ad=3.52p pd=16.88u as=3.52p ps=16.88u w=8u l=0.28u
X17 VSS TGONB TGON VSS nfet_03v3 ad=0.44p pd=2.88u as=0.44p ps=2.88u w=1u l=0.28u
X18 VDD PAD VMAX VMAX pfet_03v3 ad=0.88p pd=4.88u as=0.88p ps=4.88u w=2u l=0.28u
X19 VSS SD NNA VSS nfet_03v3 ad=0.44p pd=2.88u as=0.44p ps=2.88u w=1u l=0.28u
X20 VSS TGON GP VSS nfet_03v3 ad=0.44p pd=2.88u as=0.44p ps=2.88u w=1u l=0.28u
X21 NNO SD SHON VDD pfet_03v3 ad=0.88p pd=4.88u as=0.88p ps=4.88u w=2u l=0.28u
C0 SA GP 0.39495f
C1 TGON SEL 0.78405f
C2 PAD TGON 0.59585f
C3 VDD SA 5.83144f
C4 BUS SD 0.38749f
C5 SA SEL 6.42f
C6 SA TGON 0.32287f
C7 VMAX GP 1.98935f
C8 VDD VMAX 4.2481f
C9 VMAX SEL 0.11504f
C10 VMAX PAD 4.60897f
C11 NNO SD 0.32167f
C12 NNA TGONB 1.12144f
C13 VMAX TGON 0.94209f
C14 NNO BUS 0.12227f
C15 SHON SD 3.46318f
C16 BUS SHON 0.95304f
C17 TGONB SD 10.2925f
C18 VDD NNA 0.17276f
C19 BUS TGONB 0.34374f
C20 SEL NNA 0.219f
C21 GP SD 0.37843f
C22 TGON NNA 0.15079f
C23 VDD SD 4.3708f
C24 GP BUS 5.18503f
C25 SEL SD 3.47886f
C26 VDD BUS 0.70243f
C27 SA NNA 0.11885f
C28 NNO SHON 1.57217f
C29 TGON SD 0.65102f
C30 BUS SEL 7.824f
C31 PAD BUS 4.34092f
C32 NNO TGONB 0.13305f
C33 BUS TGON 8.356f
C34 SA SD 8.72045f
C35 SHON TGONB 3.89018f
C36 SA BUS 3.46422f
C37 GP NNO 0.12227f
C38 VDD NNO 2.3722f
C39 GP SHON 3.50252f
C40 NNO SEL 2.01232f
C41 VDD SHON 0.89803f
C42 NNO TGON 0.67613f
C43 GP TGONB 0.38194f
C44 VMAX BUS 1.20453f
C45 SHON SEL 1.02213f
C46 VDD TGONB 4.50287f
C47 SHON TGON 0.92093f
C48 SA NNO 0.12227f
C49 SEL TGONB 3.01582f
C50 TGON TGONB 5.31102f
C51 VDD GP 5.03037f
C52 SA SHON 0.30206f
C53 GP SEL 0.353f
C54 PAD GP 1.02478f
C55 NNA SD 1.75287f
C56 SA TGONB 0.36387f
C57 VDD SEL 12.5902f
C58 VDD PAD 0.63594f
C59 GP TGON 1.99001f
C60 BUS NNA 0.11642f
C61 VDD TGON 2.31377f
C62 SEL VSS 8.85534f
C63 BUS VSS 4.9353f
C64 PAD VSS 3.69298f
C65 VDD VSS 0.13376p
C66 NNA VSS 2.2243f ; **FLOATING
C67 SHON VSS 7.54063f ; **FLOATING
C68 NNO VSS 1.63732f ; **FLOATING
C69 SA VSS 8.26269f ; **FLOATING
C70 SD VSS 6.25646f ; **FLOATING
C71 TGONB VSS 5.33909f ; **FLOATING
C72 TGON VSS 11.7046f ; **FLOATING
C73 GP VSS 4.96517f ; **FLOATING
C74 VMAX VSS 65.6674f ; **FLOATING
.ends
