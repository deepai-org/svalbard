* NGSPICE file created from pt_char_atb.ext - technology: gf180mcuD

.subckt pt_char_atb RN_LNA RP_LNA RN_MIX RP_MIX RN_SMP RP_SMP RN_DRV RP_DRV RES_A
+ RES_B MIM_A MIM_B VSS
X0 RN_LNA RN_LNA VSS VSS nfet_03v3 ad=2.2p pd=10.88u as=2.2p ps=10.88u w=5u l=0.5u
X1 RN_LNA RN_LNA VSS VSS nfet_03v3 ad=4.4p pd=21.76u as=21.12p ps=0.10128m w=5u l=0.5u
X2 rb3 VSS VSS ppolyf_u_1k r_width=2u r_length=10u
X3 rb1 rb2 VSS ppolyf_u_1k r_width=2u r_length=10u
X4 MIM_B VSS cap_mim_2f0_m4m5_noshield c_width=40u c_length=40u
X5 ra2 ra3 VSS ppolyf_u_1k r_width=2u r_length=10u
X6 VSS VSS RP_SMP RP_SMP pfet_03v3 ad=4.4p pd=20.88u as=4.4p ps=20.88u w=10u l=0.28u
X7 MIM_A VSS cap_mim_2f0_m4m5_noshield c_width=40u c_length=40u
X8 VSS VSS RP_DRV RP_DRV pfet_03v3 ad=8.8p pd=40.88u as=8.8p ps=40.88u w=20u l=0.28u
X9 RES_A ra1 VSS ppolyf_u_1k r_width=2u r_length=10u
X10 RN_SMP RN_SMP VSS VSS nfet_03v3 ad=3.52p pd=16.88u as=3.52p ps=16.88u w=8u l=0.28u
X11 RN_DRV RN_DRV VSS VSS nfet_03v3 ad=8.8p pd=40.88u as=8.8p ps=40.88u w=20u l=0.5u
X12 VSS VSS RP_MIX RP_MIX pfet_03v3 ad=8.8p pd=40.88u as=8.8p ps=40.88u w=20u l=1u
X13 RN_MIX RN_MIX VSS VSS nfet_03v3 ad=2.2p pd=10.88u as=2.2p ps=10.88u w=5u l=0.28u
X14 RN_MIX RN_MIX VSS VSS nfet_03v3 ad=4.4p pd=21.76u as=0 ps=0 w=5u l=0.28u
X15 rb2 rb3 VSS ppolyf_u_1k r_width=2u r_length=10u
X16 RES_B rb1 VSS ppolyf_u_1k r_width=2u r_length=10u
X17 ra3 VSS VSS ppolyf_u_1k r_width=2u r_length=10u
X18 MIM_B VSS cap_mim_2f0_m4m5_noshield c_width=40u c_length=40u
X19 ra1 ra2 VSS ppolyf_u_1k r_width=2u r_length=10u
X20 VSS VSS RP_LNA RP_LNA pfet_03v3 ad=2.2p pd=10.88u as=2.2p ps=10.88u w=5u l=0.28u
X21 MIM_A VSS cap_mim_2f0_m4m5_noshield c_width=40u c_length=40u
X22 VSS VSS RP_LNA RP_LNA pfet_03v3 ad=0.17833n pd=0.96848m as=4.4p ps=21.76u w=5u l=0.28u
C0 rb2 RP_MIX 0.00608f
C1 RN_DRV MIM_B 0
C2 rb2 RP_DRV 0.34112f
C3 RN_DRV MIM_A 0
C4 RES_A RN_LNA 0
C5 MIM_B RP_DRV 0
C6 ra2 RP_DRV 0
C7 ra1 RES_B 0.021f
C8 MIM_A RP_DRV 0
C9 RN_SMP RN_MIX 13.25157f
C10 RN_SMP RES_B 0
C11 RP_SMP RN_MIX 0.10329f
C12 RN_DRV RN_LNA 11.5794f
C13 RES_B RP_SMP 0
C14 ra1 rb2 0.02242f
C15 RN_LNA RP_MIX 0.07424f
C16 rb2 RP_SMP 0.09239f
C17 RN_LNA RP_DRV 0.09142f
C18 ra1 ra2 0.03022f
C19 MIM_B RN_SMP 0
C20 ra1 MIM_A 0.00514f
C21 rb2 ra3 0.03044f
C22 RN_SMP MIM_A 0
C23 RP_LNA RES_A 0
C24 rb1 RP_MIX 0.15163f
C25 MIM_B ra3 0.0011f
C26 RES_B RN_MIX 0
C27 rb1 RP_DRV 0.38714f
C28 ra3 ra2 0.02274f
C29 MIM_A ra3 0.00171f
C30 RN_SMP RN_LNA 0.15794f
C31 RN_DRV RP_LNA 0.09342f
C32 RN_LNA RP_SMP 0.10571f
C33 RP_LNA RP_MIX 9.77069f
C34 MIM_B RN_MIX 0
C35 MIM_B RES_B 0
C36 RP_LNA RP_DRV 9.43237f
C37 MIM_A RN_MIX 0
C38 MIM_A RES_B 0.00442f
C39 rb1 ra1 1.51149f
C40 rb1 RP_SMP 0.07489f
C41 rb2 ra2 1.50167f
C42 rb2 MIM_A 0.00521f
C43 RN_LNA RN_MIX 11.78577f
C44 RES_B RN_LNA 0
C45 MIM_B MIM_A 7.90015f
C46 RP_LNA ra1 0
C47 MIM_A ra2 0.00337f
C48 RP_LNA RN_SMP 0.1149f
C49 RP_LNA RP_SMP 0.15557f
C50 RN_DRV RES_A 0
C51 RES_A RP_MIX 0
C52 MIM_B RN_LNA 0
C53 RES_A RP_DRV 0
C54 rb1 RES_B 0.03022f
C55 MIM_A RN_LNA 0
C56 RN_DRV RP_MIX 0.09336f
C57 rb1 rb2 0.02938f
C58 RN_DRV RP_DRV 0.11052f
C59 RP_LNA RN_MIX 0.07414f
C60 RP_LNA RES_B 0
C61 RP_DRV RP_MIX 0.44413f
C62 rb1 ra2 0
C63 rb1 MIM_A 0.00337f
C64 RES_A RN_SMP 0
C65 ra3 rb3 2.11929f
C66 MIM_B RP_LNA 0
C67 ra1 RP_MIX 0
C68 RN_DRV RN_SMP 0.37966f
C69 RN_DRV RP_SMP 0.21409f
C70 RN_SMP RP_MIX 0.10606f
C71 RP_MIX RP_SMP 10.74531f
C72 ra1 RP_DRV 0
C73 RN_SMP RP_DRV 6.87823f
C74 RP_DRV RP_SMP 0.54871f
C75 RP_LNA RN_LNA 0.07425f
C76 RES_A RN_MIX 0
C77 rb2 rb3 0.03022f
C78 RES_A RES_B 4.20537f
C79 ra3 RP_DRV 0
C80 ra2 rb3 0
C81 MIM_A rb3 0.00335f
C82 RN_DRV RN_MIX 0.81132f
C83 RN_DRV RES_B 3.55729f
C84 MIM_B RES_A 0.2425f
C85 ra1 RP_SMP 0
C86 RP_MIX RN_MIX 0.0741f
C87 RP_LNA rb1 0.00951f
C88 RES_B RP_MIX 0
C89 RES_A MIM_A 0.00306f
C90 RN_SMP RP_SMP 0.12882f
C91 RP_DRV RN_MIX 0.09131f
C92 RES_B RP_DRV 0
C93 MIM_A VSS 44.60374f
C94 RP_LNA VSS 15.7697f
C95 ra2 VSS 3.03733f $ **FLOATING
C96 MIM_B VSS 46.03772f
C97 rb1 VSS 3.58781f $ **FLOATING
C98 RES_B VSS 0.49178f
C99 rb3 VSS 3.70107f $ **FLOATING
C100 RN_MIX VSS 9.99354f
C101 RP_MIX VSS 17.83421f
C102 RN_DRV VSS 12.73278f
C103 RN_SMP VSS 8.22778f
C104 ra1 VSS 3.62168f $ **FLOATING
C105 RES_A VSS 2.80659f
C106 RP_DRV VSS 18.41794f
C107 RP_SMP VSS 15.60983f
C108 ra3 VSS 4.2448f $ **FLOATING
C109 rb2 VSS 4.50114f $ **FLOATING
C110 RN_LNA VSS 9.20609f
.ends
