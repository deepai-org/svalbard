* NGSPICE file created from pt_char_cmldiv.ext - technology: gf180mcuD

.subckt pt_char_cmldiv EN OUT BIAS VDD VSS
X0 C2 ENB cg_m VDD pfet_03v3 ad=1.76p pd=8.88u as=1.76p ps=8.88u w=4u l=0.28u
X1 CX CX VDD VDD pfet_03v3 ad=3.52p pd=16.88u as=3.52p ps=16.88u w=8u l=0.28u
X2 s0_mb s0_m s0M_h VSS nfet_03v3 ad=4.4p pd=20.88u as=4.4p ps=20.88u w=10u l=0.28u
X3 s1S_a S0B s1S_t VSS nfet_03v3 ad=13.2p pd=62.64u as=13.2p ps=62.64u w=10u l=0.28u
X4 VDD S0B VSS ppolyf_u_1k r_width=1u r_length=1.8u
X5 s1_mb S1B s1M_a VSS nfet_03v3 ad=8.8p pd=41.76u as=13.2p ps=62.64u w=10u l=0.28u
X6 BT ENB VDD VDD pfet_03v3 ad=1.76p pd=8.88u as=21.56p ps=0.10768m w=4u l=0.28u
X7 S2 S2B s2S_h VSS nfet_03v3 ad=8.8p pd=41.76u as=13.2p ps=62.64u w=10u l=0.28u
X8 S1 S1B s1S_h VSS nfet_03v3 ad=8.8p pd=41.76u as=13.2p ps=62.64u w=10u l=0.28u
X9 s0_mb S0B s0M_a VSS nfet_03v3 ad=8.8p pd=41.76u as=13.2p ps=62.64u w=10u l=0.28u
X10 OUT OB VDD VDD pfet_03v3 ad=3.52p pd=16.88u as=0 ps=0 w=8u l=0.28u
X11 VDD s0_mb VSS ppolyf_u_1k r_width=1u r_length=1.8u
X12 s0M_h VDD s0M_t VSS nfet_03v3 ad=13.2p pd=62.64u as=13.2p ps=62.64u w=10u l=0.28u
X13 D1 d1_b VDD VDD pfet_03v3 ad=1.32p pd=6.88u as=1.32p ps=6.88u w=3u l=0.28u
X14 CY S2B CT VSS nfet_03v3 ad=4.4p pd=20.88u as=13.2p ps=62.64u w=10u l=0.28u
X15 s1M_a S0 s1M_t VSS nfet_03v3 ad=0 pd=0 as=13.2p ps=62.64u w=10u l=0.28u
X16 S2 s2_mb s2S_a VSS nfet_03v3 ad=0 pd=0 as=13.2p ps=62.64u w=10u l=0.28u
X17 BT BIAS VSS ppolyf_u_1k r_width=1u r_length=36u
X18 S0B s0_m s0S_a VSS nfet_03v3 ad=8.8p pd=41.76u as=13.2p ps=62.64u w=10u l=0.28u
X19 OB D1 VDD VDD pfet_03v3 ad=1.76p pd=8.88u as=0 ps=0 w=4u l=0.28u
X20 D1 C2 d1_x3 VSS nfet_03v3 ad=0.88p pd=4.88u as=0.88p ps=4.88u w=2u l=0.28u
X21 VDD s2_m VSS ppolyf_u_1k r_width=1u r_length=1.8u
X22 s2_m s2_mb s2M_h VSS nfet_03v3 ad=8.8p pd=41.76u as=13.2p ps=62.64u w=10u l=0.28u
X23 s1_m s1_mb s1M_h VSS nfet_03v3 ad=8.8p pd=41.76u as=13.2p ps=62.64u w=10u l=0.28u
X24 s0M_t BIAS VSS VSS nfet_03v3 ad=4.4p pd=20.88u as=4.4p ps=20.88u w=10u l=0.5u
X25 CT BIAS VSS VSS nfet_03v3 ad=0 pd=0 as=40.04p ps=0.19872m w=10u l=0.5u
X26 s2S_h S1 s2S_t VSS nfet_03v3 ad=0 pd=0 as=13.2p ps=62.64u w=10u l=0.28u
X27 OUT OB VSS VSS nfet_03v3 ad=1.76p pd=8.88u as=1.76p ps=8.88u w=4u l=0.28u
X28 s2_m S2 s2M_a VSS nfet_03v3 ad=0 pd=0 as=13.2p ps=62.64u w=10u l=0.28u
X29 s0S_a VDD s0S_t VSS nfet_03v3 ad=0 pd=0 as=13.2p ps=62.64u w=10u l=0.28u
X30 BIAS BIAS VSS VSS nfet_03v3 ad=0.44p pd=2.88u as=0.44p ps=2.88u w=1u l=0.5u
X31 d1_x2 C2 VSS VSS nfet_03v3 ad=1.76p pd=9.76u as=0 ps=0 w=2u l=0.28u
X32 VDD S2 VSS ppolyf_u_1k r_width=1u r_length=1.8u
X33 C1 CY VDD VDD pfet_03v3 ad=1.76p pd=8.88u as=0 ps=0 w=4u l=0.28u
X34 s2S_t BIAS VSS VSS nfet_03v3 ad=0 pd=0 as=0 ps=0 w=10u l=0.5u
X35 VDD S1 VSS ppolyf_u_1k r_width=1u r_length=1.8u
X36 S0 S0B s0S_h VSS nfet_03v3 ad=8.8p pd=41.76u as=13.2p ps=62.64u w=10u l=0.28u
X37 OB D1 VSS VSS nfet_03v3 ad=0.88p pd=4.88u as=0 ps=0 w=2u l=0.28u
X38 s2M_h S1B s2M_t VSS nfet_03v3 ad=0 pd=0 as=13.2p ps=62.64u w=10u l=0.28u
X39 d1_x1 D1 VDD VDD pfet_03v3 ad=0.88p pd=4.88u as=0.88p ps=4.88u w=2u l=0.28u
X40 S1 s1_mb s1S_a VSS nfet_03v3 ad=0 pd=0 as=0 ps=0 w=10u l=0.28u
X41 CY CX VDD VDD pfet_03v3 ad=3.52p pd=16.88u as=0 ps=0 w=8u l=0.28u
X42 C2 C1 VSS VSS nfet_03v3 ad=1.76p pd=9.76u as=0 ps=0 w=2u l=0.28u
X43 VDD s1_m VSS ppolyf_u_1k r_width=1u r_length=1.8u
X44 S0 s0_mb s0S_a VSS nfet_03v3 ad=0 pd=0 as=0 ps=0 w=10u l=0.28u
X45 s0_m s0_mb s0M_h VSS nfet_03v3 ad=8.8p pd=41.76u as=0 ps=0 w=10u l=0.28u
X46 d1_x3 d1_b VSS VSS nfet_03v3 ad=1.76p pd=9.76u as=0 ps=0 w=2u l=0.28u
X47 s2M_t BIAS VSS VSS nfet_03v3 ad=0 pd=0 as=0 ps=0 w=10u l=0.5u
X48 ENB EN VSS VSS nfet_03v3 ad=0.44p pd=2.88u as=0.44p ps=2.88u w=1u l=0.28u
X49 cg_m C1 VDD VDD pfet_03v3 ad=3.52p pd=17.76u as=0 ps=0 w=4u l=0.28u
X50 s1S_h S0 s1S_t VSS nfet_03v3 ad=0 pd=0 as=0 ps=0 w=10u l=0.28u
X51 C1 CY VSS VSS nfet_03v3 ad=0.88p pd=4.88u as=0 ps=0 w=2u l=0.28u
X52 s1_m S1 s1M_a VSS nfet_03v3 ad=0 pd=0 as=0 ps=0 w=10u l=0.28u
X53 s0_m S0 s0M_a VSS nfet_03v3 ad=0 pd=0 as=0 ps=0 w=10u l=0.28u
X54 VDD S2B VSS ppolyf_u_1k r_width=1u r_length=1.8u
X55 VDD S0 VSS ppolyf_u_1k r_width=1u r_length=1.8u
X56 s1S_t BIAS VSS VSS nfet_03v3 ad=0 pd=0 as=0 ps=0 w=10u l=0.5u
X57 ENB EN VDD VDD pfet_03v3 ad=0.88p pd=4.88u as=0 ps=0 w=2u l=0.28u
X58 S2B S2 s2S_h VSS nfet_03v3 ad=8.8p pd=41.76u as=0 ps=0 w=10u l=0.28u
X59 s1M_h S0B s1M_t VSS nfet_03v3 ad=0 pd=0 as=0 ps=0 w=10u l=0.28u
X60 VDD s2_mb VSS ppolyf_u_1k r_width=1u r_length=1.8u
X61 s0M_a VDD s0M_t VSS nfet_03v3 ad=0 pd=0 as=0 ps=0 w=10u l=0.28u
X62 CX S2 CT VSS nfet_03v3 ad=4.4p pd=20.88u as=0 ps=0 w=10u l=0.28u
X63 s1M_t BIAS VSS VSS nfet_03v3 ad=0 pd=0 as=0 ps=0 w=10u l=0.5u
X64 VDD s0_m VSS ppolyf_u_1k r_width=1u r_length=1.8u
X65 S2B s2_m s2S_a VSS nfet_03v3 ad=0 pd=0 as=0 ps=0 w=10u l=0.28u
X66 s0S_h VDD s0S_t VSS nfet_03v3 ad=0 pd=0 as=0 ps=0 w=10u l=0.28u
X67 s2_mb s2_m s2M_h VSS nfet_03v3 ad=8.8p pd=41.76u as=0 ps=0 w=10u l=0.28u
X68 s1_mb s1_m s1M_h VSS nfet_03v3 ad=0 pd=0 as=0 ps=0 w=10u l=0.28u
X69 BIAS ENB VSS VSS nfet_03v3 ad=0.88p pd=5.76u as=0 ps=0 w=1u l=0.28u
X70 d1_b C2 VDD VDD pfet_03v3 ad=0.88p pd=4.88u as=0 ps=0 w=2u l=0.28u
X71 VDD S1B VSS ppolyf_u_1k r_width=1u r_length=1.8u
X72 s2S_a S1B s2S_t VSS nfet_03v3 ad=0 pd=0 as=0 ps=0 w=10u l=0.28u
X73 s0S_t BIAS VSS VSS nfet_03v3 ad=0 pd=0 as=0 ps=0 w=10u l=0.5u
X74 d1_b d1_a d1_x2 VSS nfet_03v3 ad=0.88p pd=4.88u as=0 ps=0 w=2u l=0.28u
X75 s2_mb S2B s2M_a VSS nfet_03v3 ad=0 pd=0 as=0 ps=0 w=10u l=0.28u
X76 d1_a C2 d1_x1 VDD pfet_03v3 ad=0.88p pd=4.88u as=1.76p ps=9.76u w=2u l=0.28u
X77 C2 ENB VSS VSS nfet_03v3 ad=0 pd=0 as=0 ps=0 w=2u l=0.28u
X78 S1B S1 s1S_h VSS nfet_03v3 ad=8.8p pd=41.76u as=0 ps=0 w=10u l=0.28u
X79 S0B S0 s0S_h VSS nfet_03v3 ad=0 pd=0 as=0 ps=0 w=10u l=0.28u
X80 D1 ENB VSS VSS nfet_03v3 ad=1.32p pd=7.76u as=0 ps=0 w=1u l=0.28u
X81 VDD s1_mb VSS ppolyf_u_1k r_width=1u r_length=1.8u
X82 d1_a D1 VSS VSS nfet_03v3 ad=0.44p pd=2.88u as=0 ps=0 w=1u l=0.28u
X83 s2M_a S1 s2M_t VSS nfet_03v3 ad=0 pd=0 as=0 ps=0 w=10u l=0.28u
X84 S1B s1_m s1S_a VSS nfet_03v3 ad=0 pd=0 as=0 ps=0 w=10u l=0.28u
C0 S0B S1 0.04215f
C1 S0 BIAS 1.00667f
C2 S1B BIAS 0.16469f
C3 s2S_a VDD 0
C4 D1 cg_m 0.19092f
C5 d1_b d1_x1 2.68354f
C6 VDD s0M_t 0.17123f
C7 s2_m s1S_t 0.76448f
C8 C2 OB 0.11093f
C9 s2S_t s2S_h 1.27067f
C10 CT CY 1.19977f
C11 CX s2S_h 0.18052f
C12 VDD S0 4.20493f
C13 s1M_a S1 0.16673f
C14 S2 BIAS 3.96927f
C15 s1M_a S0B 0
C16 C2 s2_mb 0.63761f
C17 S1B VDD 0.06078f
C18 D1 d1_x1 1.25929f
C19 D1 d1_b 2.5799f
C20 s0S_t S0 0.76448f
C21 S2 VDD 0.25475f
C22 d1_x3 d1_x1 0.01036f
C23 S0B s0_mb 2.16187f
C24 C2 S1 0
C25 S0B s1M_t 0.08588f
C26 d1_b d1_x3 0.0693f
C27 d1_x2 d1_a 0.17721f
C28 BIAS s1S_t 0.13671f
C29 D1 d1_x3 0.9607f
C30 s2_m s1M_h 0.2171f
C31 s2M_h s2_m 2.18886f
C32 s2_mb s2S_h 0.04036f
C33 s1M_a s1M_t 1.22489f
C34 ENB S2B 0.04116f
C35 BIAS OUT 0.11469f
C36 s2S_h S1 0.08934f
C37 C1 S2B 0.09094f
C38 S0B s0M_h 0.28826f
C39 s2_m CY 0.08649f
C40 VDD OUT 4.19415f
C41 ENB s0M_t 0.00263f
C42 s2M_h BIAS 0.04663f
C43 ENB S0 2.36924f
C44 ENB S1B 0.04829f
C45 C1 s2S_a 0.14524f
C46 C2 s2S_h 1.37455f
C47 s2_m s1_mb 0.23225f
C48 s2M_h VDD 0.20456f
C49 s0M_h s0_mb 1.7556f
C50 S2B s2S_t 0.20708f
C51 ENB S2 0.51687f
C52 s0S_a s0S_h 0.79233f
C53 S2B CX 1.07908f
C54 C1 S1B 0.05011f
C55 BIAS CY 0.05171f
C56 s0M_a VDD 0.08579f
C57 S2B s1_m 0.04984f
C58 S2 C1 0.22877f
C59 VDD CY 3.70678f
C60 s2S_a s2S_t 1.38024f
C61 s1S_h S0 0.0854f
C62 s1S_h s1S_a 0.74554f
C63 s2S_a CX 0.18355f
C64 s1S_h S1B 1.62987f
C65 VDD cg_m 2.32328f
C66 BIAS s1_mb 0.083f
C67 s0S_h S0 1.50675f
C68 s2_mb S2B 2.85502f
C69 S1B s2S_t 0.08621f
C70 EN S0 0.00701f
C71 VDD d1_x1 2.99665f
C72 VDD s1_mb 0.02348f
C73 ENB OUT 0.00187f
C74 d1_x2 C2 0.103f
C75 d1_b VDD 3.75284f
C76 S2 s2S_t 0.13064f
C77 BIAS s0_m 1.04758f
C78 s1_m S0 0.05312f
C79 S2B S1 0.83373f
C80 S2 CX 0.30137f
C81 S2B S0B 0.05277f
C82 s1_m s1S_a 0.08563f
C83 S1B s1_m 0.3528f
C84 D1 VDD 5.00687f
C85 s0S_a S0B 2.40353f
C86 s2_mb s2S_a 0.19556f
C87 BT BIAS 0.29913f
C88 VDD s0_m 0.41997f
C89 CT BIAS 0.13671f
C90 S2 s1_m 0.05221f
C91 S2B s1M_a 0.08429f
C92 ENB s2M_h 0.12671f
C93 s1S_h s1S_t 1.19877f
C94 d1_a OUT 0.23555f
C95 VDD d1_x3 0.32477f
C96 s2M_t S1B 0.08639f
C97 s2_mb s1S_a 0
C98 S1B s2_mb 0.24831f
C99 BT VDD 1.77863f
C100 s0S_t s0_m 0
C101 s2S_a S1 0
C102 S0B s0M_t 0.61877f
C103 C2 S2B 0.56394f
C104 s2M_h C1 0.09778f
C105 S2 s2_mb 0.37105f
C106 s0S_a s0_mb 0.09722f
C107 S0 S1 0.04236f
C108 S0B S0 11.54519f
C109 s1S_a S1 1.27099f
C110 S1B S1 7.44732f
C111 ENB CY 0.3009f
C112 S1B S0B 0.05317f
C113 S0B s1S_a 0.0854f
C114 s1_m s1S_t 0.00577f
C115 s2M_a s2M_t 1.59265f
C116 s2M_a s2_mb 1.5477f
C117 EN OUT 2.11162f
C118 S2 S1 0.04261f
C119 ENB cg_m 0.42399f
C120 s1M_a S0 0.0854f
C121 S2 S0B 0.17255f
C122 S1B s1M_a 0.16457f
C123 s1S_h s2M_h 0
C124 s0M_t s0_mb 0.00126f
C125 C1 CY 9.67464f
C126 C2 s2S_a 0.15287f
C127 d1_a CY 0
C128 ENB d1_x1 0.86732f
C129 s2M_a S1 0.08607f
C130 s2_mb s1S_t 0
C131 s2M_h s2S_t 0.22653f
C132 S2B s2S_h 1.57901f
C133 S2 s1M_a 0.06497f
C134 S0 s0_mb 0.36296f
C135 ENB s1_mb 0.01229f
C136 ENB d1_b 0.00412f
C137 C1 cg_m 0.10261f
C138 s2_m BIAS 0.14797f
C139 s1M_t S0 0.0892f
C140 s2M_h CX 0.02833f
C141 C2 S1B 0
C142 OB OUT 0.39618f
C143 ENB D1 0.6347f
C144 C1 d1_x1 0.04507f
C145 s1S_t S1 0
C146 S0B s1S_t 0.08583f
C147 s1_m s1M_h 1.55071f
C148 s2_m VDD 0.27951f
C149 ENB s0_m 0
C150 S2 s1M_t 0.12778f
C151 S2 C2 0.15215f
C152 d1_a d1_x1 1.22897f
C153 s2S_t CY 0.07014f
C154 s2S_a s2S_h 0.1665f
C155 d1_a d1_b 0.10534f
C156 ENB d1_x3 0
C157 CX CY 0.30071f
C158 ENB BT 1.61606f
C159 D1 C1 0.26693f
C160 s0M_h s0M_t 1.19877f
C161 d1_a D1 0.07163f
C162 s2M_t s2M_h 1.19877f
C163 s2_mb s1M_h 0
C164 s2M_h s2_mb 9.02543f
C165 CX cg_m 0.11416f
C166 s0M_h S0 0.17909f
C167 s1S_h s1_mb 0.00416f
C168 S2 s2S_h 1.64018f
C169 C1 CT 0
C170 CX d1_x1 0.00665f
C171 s1M_h S1 0.04866f
C172 s2M_h S1 1.65328f
C173 VDD BIAS 2.49857f
C174 S0B s1M_h 0.0854f
C175 s2_mb CY 0.14076f
C176 OB cg_m 0.06149f
C177 s0S_h s0_m 0
C178 C2 OUT 0.0702f
C179 D1 CX 1.72103f
C180 s1_m s1_mb 2.4832f
C181 s2M_h s1M_a 0
C182 s1M_a s1M_h 0.15547f
C183 s0S_t BIAS 0.13671f
C184 S0B s0M_a 0.36055f
C185 OB d1_x1 0.13179f
C186 CY S1 0.03838f
C187 OB d1_b 0.10902f
C188 s0S_t VDD 0.17123f
C189 EN BT 0.07184f
C190 C2 s2M_h 0
C191 CX CT 1.628f
C192 s1M_t s1M_h 1.12687f
C193 s2_mb s1_mb 0
C194 ENB s2_m 0.20459f
C195 D1 OB 2.29546f
C196 s0M_a s0_mb 2.55673f
C197 s1_mb S1 0.36693f
C198 OB d1_x3 0.11164f
C199 S0B s1_mb 0.05296f
C200 C1 s2_m 0.09241f
C201 C2 CY 0.21135f
C202 S2B s2S_a 1.59914f
C203 s2M_h s2S_h 0.11993f
C204 s1M_a s1_mb 2.25387f
C205 C2 cg_m 1.25151f
C206 S0B s0_m 3.07464f
C207 S2B S0 0.04301f
C208 S1B S2B 4.17545f
C209 ENB BIAS 1.42112f
C210 s1S_h s2_m 0.40107f
C211 s0S_a S0 1.29455f
C212 C2 d1_x1 0.46024f
C213 BT S0B 0.11122f
C214 s1M_t s1_mb 0
C215 C2 d1_b 0.6889f
C216 s2S_t s2_m 0.48694f
C217 S2 S2B 1.05742f
C218 ENB VDD 8.27235f
C219 s2S_h CY 0.00241f
C220 s0M_h s0M_a 0.18531f
C221 s2_m CX 0.00347f
C222 C1 BIAS 0.09958f
C223 d1_x2 OUT 0.10458f
C224 C2 D1 0.22625f
C225 s0_m s0_mb 2.62746f
C226 s2M_a S2B 0.08605f
C227 S1B s2S_a 0.08638f
C228 S0 s0M_t 0.87854f
C229 s1_m s2_m 1.44173f
C230 C1 VDD 3.04173f
C231 C2 d1_x3 0.02579f
C232 d1_a VDD 1.96451f
C233 S1B S0 0.04273f
C234 S0 s1S_a 0
C235 S2 s2S_a 2.8298f
C236 S1B s1S_a 1.38593f
C237 C2 CT 0.31742f
C238 S2 S0 2.31798f
C239 s2M_t s2_m 0.76448f
C240 s2S_t BIAS 0.13671f
C241 s2_mb s2_m 0.33898f
C242 S2 S1B 0.64889f
C243 EN BIAS 17.88625f
C244 CX BIAS 0.00613f
C245 s0S_h VDD 0.0854f
C246 s2M_a S1B 0.00102f
C247 s0M_h s0_m 1.66657f
C248 s2_m S1 0.31568f
C249 EN VDD 1.76193f
C250 s1_m BIAS 0.04327f
C251 CX VDD 7.15971f
C252 S0B s2_m 0.09144f
C253 CT s2S_h 0
C254 s0S_t s0S_h 1.19877f
C255 S2 s2M_a 0.0854f
C256 S0 s1S_t 0.0854f
C257 S1B s1S_t 0
C258 s1M_a s2_m 0.15492f
C259 s1_m VDD 0.04008f
C260 s1S_a s1S_t 1.59265f
C261 S2B s1M_h 0.05702f
C262 s2M_h S2B 0.30463f
C263 s2M_t BIAS 0.13671f
C264 s2_mb BIAS 0.09503f
C265 d1_x2 d1_x1 0.03167f
C266 OB VDD 3.39604f
C267 d1_x2 d1_b 0.85994f
C268 s2_m s1M_t 0.01936f
C269 C2 s2_m 0.00289f
C270 s2_mb VDD 0.22515f
C271 ENB C1 4.59726f
C272 BIAS S1 0.14735f
C273 S2B CY 0.26075f
C274 S0B BIAS 3.02609f
C275 s2M_h s2S_a 0.06772f
C276 d1_x2 D1 0
C277 ENB d1_a 0.18467f
C278 VDD S1 0.1798f
C279 d1_x2 d1_x3 0.11229f
C280 S0B VDD 0.73588f
C281 s2M_h s1S_a 0
C282 S1B s1M_h 0.05787f
C283 s2M_h S1B 2.98881f
C284 d1_a C1 0.02079f
C285 s0M_a s0M_t 1.29625f
C286 s2S_a CY 0.15287f
C287 s2_m s2S_h 0
C288 S2B s1_mb 0.07402f
C289 S2 s1M_h 0.06825f
C290 S2 s2M_h 0.093f
C291 s0S_t S0B 0.60857f
C292 BIAS s0_mb 0.06724f
C293 ENB s2S_t 0.01723f
C294 C2 BIAS 0
C295 s1M_t BIAS 0.1372f
C296 s0M_a S0 0.32045f
C297 ENB EN 0.1777f
C298 ENB CX 1.3569f
C299 s2M_a s2M_h 0.17008f
C300 S1B CY 0.05193f
C301 VDD s0_mb 0.13051f
C302 s1M_t VDD 0.01496f
C303 C2 VDD 3.58363f
C304 C1 s2S_t 0.08988f
C305 ENB s1_m 0.12031f
C306 S2 CY 5.39407f
C307 s0S_a s0_m 0.08562f
C308 C1 CX 0.21658f
C309 s0S_t s0_mb 0.01182f
C310 d1_a CX 0
C311 S2B CT 0.09374f
C312 ENB OB 0.06851f
C313 S0 s1_mb 0.05314f
C314 s1_mb s1S_a 0.09722f
C315 S1B s1_mb 0.14893f
C316 ENB s2_mb 1.69624f
C317 s0M_t s0_m 0.00241f
C318 S2 s1_mb 0.07289f
C319 S0 s0_m 0.52971f
C320 s0M_h VDD 0.08539f
C321 s2S_t CX 0.00377f
C322 ENB S1 0.03819f
C323 C1 s2_mb 0.64561f
C324 ENB S0B 0.14317f
C325 s1S_h s1_m 0
C326 BT S0 1.42556f
C327 s0S_t s0M_h 0
C328 s2M_h s1M_h 0
C329 ENB s1M_a 0.01907f
C330 C1 S1 0.0383f
C331 s1_mb s1S_t 0.0254f
C332 S2 BT 0.00733f
C333 s1S_h s2M_t 0
C334 s1S_h s2_mb 0
C335 S2 CT 0.08601f
C336 OB CX 0.02728f
C337 S2B s2_m 8.74649f
C338 s2_mb s2S_t 0.09493f
C339 ENB s1M_t 0.11934f
C340 ENB C2 1.03346f
C341 s2M_h CY 0.09153f
C342 OUT d1_x1 0.16867f
C343 s2_mb CX 0.08743f
C344 s1S_h S1 1.58145f
C345 d1_b OUT 0.20656f
C346 d1_x2 VDD 0.41008f
C347 s2S_t S1 0.08686f
C348 S0B s0S_h 1.7285f
C349 s2_mb s1_m 0
C350 C2 C1 2.95904f
C351 D1 OUT 0.28148f
C352 EN S0B 0.00145f
C353 d1_a C2 0.80279f
C354 s2S_a s2_m 0.16323f
C355 s2M_h s1_mb 0
C356 s1M_h s1_mb 2.94749f
C357 d1_x3 OUT 0.10465f
C358 s1_m S1 1.74985f
C359 s2_m S0 2.17646f
C360 S0B s1_m 0.04412f
C361 S2B BIAS 0.20168f
C362 s2M_t s2_mb 0.04419f
C363 s2_m s1S_a 0.49473f
C364 S1B s2_m 0.70096f
C365 s0S_h s0_mb 0.00416f
C366 CY d1_x1 0.01535f
C367 C2 s2S_t 0.61456f
C368 S2B VDD 0.19544f
C369 s1M_a s1_m 2.26032f
C370 S2 s2_m 5.35703f
C371 C1 s2S_h 1.22265f
C372 s2M_t S1 0.08944f
C373 s2_mb S1 3.37406f
C374 C2 CX 0.42483f
C375 s0S_a VDD 0.08581f
C376 cg_m d1_x1 0.09299f
C377 s2M_a s2_m 1.61629f
C378 BIAS s0M_t 0.1456f
C379 d1_b cg_m 0
C380 D1 CY 0.5827f
C381 s0M_a s0_m 1.51496f
C382 s1_m s1M_t 0.62054f
C383 s2_mb s1M_a 0
C384 s0S_a s0S_t 1.29685f
C385 s2M_a VSS 3.24388f $ **FLOATING
C386 s2M_t VSS 4.27351f $ **FLOATING
C387 d1_a VSS 4.21066f $ **FLOATING
C388 s2_mb VSS 10.57203f $ **FLOATING
C389 S2B VSS 10.37611f $ **FLOATING
C390 d1_b VSS 3.11715f $ **FLOATING
C391 s0S_t VSS 4.32856f $ **FLOATING
C392 s2S_a VSS 4.76037f $ **FLOATING
C393 s2S_t VSS 4.74247f $ **FLOATING
C394 s1_m VSS 6.52091f $ **FLOATING
C395 s2_m VSS 9.92696f $ **FLOATING
C396 s0S_h VSS 3.46453f $ **FLOATING
C397 s1M_t VSS 4.3033f $ **FLOATING
C398 CX VSS 3.05126f $ **FLOATING
C399 CT VSS 4.9744f $ **FLOATING
C400 s0M_a VSS 4.39135f $ **FLOATING
C401 VDD VSS 94.59605f
C402 s1M_h VSS 4.73173f $ **FLOATING
C403 s1S_t VSS 4.41323f $ **FLOATING
C404 S0 VSS 12.07065f $ **FLOATING
C405 S1 VSS 13.60255f $ **FLOATING
C406 C1 VSS 6.40261f $ **FLOATING
C407 CY VSS 5.65153f $ **FLOATING
C408 s1S_h VSS 4.10836f $ **FLOATING
C409 cg_m VSS 0.78519f $ **FLOATING
C410 ENB VSS 14.43481f $ **FLOATING
C411 EN VSS 11.54934f
C412 s0_mb VSS 8.1118f $ **FLOATING
C413 C2 VSS 9.3806f $ **FLOATING
C414 d1_x1 VSS 1.2744f $ **FLOATING
C415 D1 VSS 7.8075f $ **FLOATING
C416 s2M_h VSS 6.17212f $ **FLOATING
C417 OB VSS 6.0747f $ **FLOATING
C418 d1_x2 VSS 2.40432f $ **FLOATING
C419 s0S_a VSS 3.48035f $ **FLOATING
C420 S2 VSS 11.68266f $ **FLOATING
C421 OUT VSS 6.46743f
C422 s2S_h VSS 3.81763f $ **FLOATING
C423 s0M_t VSS 4.33327f $ **FLOATING
C424 BIAS VSS 38.33895f
C425 s1_mb VSS 6.82942f $ **FLOATING
C426 d1_x3 VSS 2.48566f $ **FLOATING
C427 BT VSS 1.83227f $ **FLOATING
C428 s1M_a VSS 3.48729f $ **FLOATING
C429 s0M_h VSS 6.09103f $ **FLOATING
C430 S0B VSS 14.86131f $ **FLOATING
C431 S1B VSS 12.05725f $ **FLOATING
C432 s1S_a VSS 3.58444f $ **FLOATING
C433 s0_m VSS 10.8252f $ **FLOATING
.ends
