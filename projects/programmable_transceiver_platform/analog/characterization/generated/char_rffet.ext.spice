* NGSPICE file created from pt_char_rffet.ext - technology: gf180mcuD

.subckt rf_dev a_n508_n396# a_n626_n200# a_200_n396# a_500_n200# a_n444_n200# a_n36_n396#
+ a_436_n396# a_264_n200# a_n208_n200# a_n272_n396# a_n764_n490# a_28_n200#
X0 a_28_n200# a_n36_n396# a_n208_n200# a_n764_n490# nfet_03v3 ad=0.9p pd=2.9u as=0.9p ps=2.9u w=2u l=0.28u
X1 a_264_n200# a_200_n396# a_28_n200# a_n764_n490# nfet_03v3 ad=0.9p pd=2.9u as=0.9p ps=2.9u w=2u l=0.28u
X2 a_500_n200# a_436_n396# a_264_n200# a_n764_n490# nfet_03v3 ad=1.26p pd=5.26u as=0.9p ps=2.9u w=2u l=0.28u
X3 a_n208_n200# a_n272_n396# a_n444_n200# a_n764_n490# nfet_03v3 ad=0.9p pd=2.9u as=0.9p ps=2.9u w=2u l=0.28u
X4 a_n444_n200# a_n508_n396# a_n626_n200# a_n764_n490# nfet_03v3 ad=0.9p pd=2.9u as=1.26p ps=5.26u w=2u l=0.28u
C0 a_n36_n396# a_200_n396# 0.05032f
C1 a_n444_n200# a_n508_n396# 0.01471f
C2 a_n508_n396# a_n626_n200# 0.01471f
C3 a_n208_n200# a_28_n200# 0.10732f
C4 a_500_n200# a_436_n396# 0.01471f
C5 a_264_n200# a_436_n396# 0.01471f
C6 a_n444_n200# a_n272_n396# 0.01471f
C7 a_n208_n200# a_n272_n396# 0.01471f
C8 a_264_n200# a_28_n200# 0.10732f
C9 a_200_n396# a_436_n396# 0.05032f
C10 a_n508_n396# a_n272_n396# 0.05032f
C11 a_n36_n396# a_n208_n200# 0.01471f
C12 a_264_n200# a_500_n200# 0.10732f
C13 a_28_n200# a_200_n396# 0.01471f
C14 a_n36_n396# a_28_n200# 0.01471f
C15 a_264_n200# a_200_n396# 0.01471f
C16 a_n444_n200# a_n626_n200# 0.10732f
C17 a_n36_n396# a_n272_n396# 0.05032f
C18 a_n444_n200# a_n208_n200# 0.10732f
C19 a_500_n200# a_n764_n490# 0.24266f
C20 a_264_n200# a_n764_n490# 0.03992f
C21 a_28_n200# a_n764_n490# 0.03987f
C22 a_n208_n200# a_n764_n490# 0.03987f
C23 a_n444_n200# a_n764_n490# 0.03992f
C24 a_n626_n200# a_n764_n490# 0.24266f
C25 a_436_n396# a_n764_n490# 0.47037f
C26 a_200_n396# a_n764_n490# 0.41364f
C27 a_n36_n396# a_n764_n490# 0.41301f
C28 a_n272_n396# a_n764_n490# 0.41364f
C29 a_n508_n396# a_n764_n490# 0.47037f
.ends

.subckt pt_char_rffet G D GND
Xrf_dev_0 G GND G D D G G GND GND G GND D rf_dev
C0 D G 0.60178f
C1 D GND 44.06238f
C2 G GND 45.48605f
.ends
