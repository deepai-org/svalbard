* NGSPICE file created from pt_char_rffet_open.ext - technology: gf180mcuD

.subckt pt_char_rffet_open G D GND
C0 D GND 4.78526f
C1 GND G 4.78526f
C2 GND VSUBS 0.24178p
C3 D VSUBS 37.5788f
C4 G VSUBS 38.1903f
.ends
