* NGSPICE file created from pt_char_rffet_open.ext - technology: gf180mcuD

.subckt pt_char_rffet_open G D GND
.ends
