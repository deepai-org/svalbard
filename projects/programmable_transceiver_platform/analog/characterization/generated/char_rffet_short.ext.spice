* NGSPICE file created from pt_char_rffet_short.ext - technology: gf180mcuD

.subckt pt_char_rffet_short GND
C0 GND VSUBS 0.31896p
.ends
