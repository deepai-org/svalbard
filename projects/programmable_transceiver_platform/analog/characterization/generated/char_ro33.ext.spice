* NGSPICE file created from pt_char_ro33.ext - technology: gf180mcuD

.subckt pt_char_ro33 EN OUT VDD VSS
X0 d1_b T0 VDD VDD pfet_03v3 ad=0.88p pd=4.88u as=0.88p ps=4.88u w=2u l=0.28u
X1 d1_b d1_a d1_x2 VSS nfet_03v3 ad=0.88p pd=4.88u as=0.88p ps=4.88u w=2u l=0.28u
X2 d1_a T0 d1_x1 VDD pfet_03v3 ad=0.88p pd=4.88u as=1.76p ps=9.76u w=2u l=0.28u
X3 T0 ENB VSS VSS nfet_03v3 ad=1.76p pd=9.76u as=29.48p ps=0.15512m w=2u l=0.28u
X4 R0 R10 VDD VDD pfet_03v3 ad=3.52p pd=16.88u as=3.52p ps=16.88u w=8u l=0.28u
X5 D1 ENB VSS VSS nfet_03v3 ad=0.44p pd=2.88u as=0.44p ps=2.88u w=1u l=0.28u
X6 d1_a D1 VSS VSS nfet_03v3 ad=0.44p pd=2.88u as=0 ps=0 w=1u l=0.28u
X7 R7 R6 VDD VDD pfet_03v3 ad=3.52p pd=16.88u as=56.32p ps=0.27536m w=8u l=0.28u
X8 R3 R2 VSS VSS nfet_03v3 ad=1.76p pd=8.88u as=1.76p ps=8.88u w=4u l=0.28u
X9 T0 ENB tap_m VDD pfet_03v3 ad=1.76p pd=8.88u as=1.76p ps=8.88u w=4u l=0.28u
X10 R8 R7 VSS VSS nfet_03v3 ad=1.76p pd=8.88u as=0 ps=0 w=4u l=0.28u
X11 d2_x3 d2_b VSS VSS nfet_03v3 ad=1.76p pd=9.76u as=0 ps=0 w=2u l=0.28u
X12 R6 R5 VDD VDD pfet_03v3 ad=3.52p pd=16.88u as=0 ps=0 w=8u l=0.28u
X13 R2 R1 VSS VSS nfet_03v3 ad=1.76p pd=8.88u as=0 ps=0 w=4u l=0.28u
X14 R5 R4 VDD VDD pfet_03v3 ad=3.52p pd=16.88u as=0 ps=0 w=8u l=0.28u
X15 R7 R6 VSS VSS nfet_03v3 ad=1.76p pd=8.88u as=0 ps=0 w=4u l=0.28u
X16 R1 R0 VSS VSS nfet_03v3 ad=1.76p pd=8.88u as=0 ps=0 w=4u l=0.28u
X17 d2_b D1 VDD VDD pfet_03v3 ad=0.88p pd=4.88u as=0 ps=0 w=2u l=0.28u
X18 D1 d1_b VDD VDD pfet_03v3 ad=1.32p pd=6.88u as=1.32p ps=6.88u w=3u l=0.28u
X19 R2 R1 VDD VDD pfet_03v3 ad=3.52p pd=16.88u as=0 ps=0 w=8u l=0.28u
X20 d2_b d2_a d2_x2 VSS nfet_03v3 ad=0.88p pd=4.88u as=1.76p ps=9.76u w=2u l=0.28u
X21 R4 R3 VDD VDD pfet_03v3 ad=3.52p pd=16.88u as=0 ps=0 w=8u l=0.28u
X22 R6 R5 VSS VSS nfet_03v3 ad=1.76p pd=8.88u as=0 ps=0 w=4u l=0.28u
X23 d2_a D1 d2_x1 VDD pfet_03v3 ad=0.88p pd=4.88u as=1.76p ps=9.76u w=2u l=0.28u
X24 D1 T0 d1_x3 VSS nfet_03v3 ad=1.32p pd=7.76u as=1.76p ps=9.76u w=2u l=0.28u
X25 D2 ENB VSS VSS nfet_03v3 ad=1.32p pd=7.76u as=0 ps=0 w=1u l=0.28u
X26 R1 R0 VDD VDD pfet_03v3 ad=3.52p pd=16.88u as=0 ps=0 w=8u l=0.28u
X27 R5 R4 VSS VSS nfet_03v3 ad=1.76p pd=8.88u as=0 ps=0 w=4u l=0.28u
X28 d2_a D2 VSS VSS nfet_03v3 ad=0.44p pd=2.88u as=0 ps=0 w=1u l=0.28u
X29 R3 R2 VDD VDD pfet_03v3 ad=3.52p pd=16.88u as=0 ps=0 w=8u l=0.28u
X30 R0 R10 en_m VSS nfet_03v3 ad=1.76p pd=8.88u as=3.52p ps=17.76u w=4u l=0.28u
X31 d1_x2 T0 VSS VSS nfet_03v3 ad=1.76p pd=9.76u as=0 ps=0 w=2u l=0.28u
X32 ENB EN VDD VDD pfet_03v3 ad=0.88p pd=4.88u as=0 ps=0 w=2u l=0.28u
X33 R0 EN VDD VDD pfet_03v3 ad=7.04p pd=33.76u as=0 ps=0 w=8u l=0.28u
X34 R4 R3 VSS VSS nfet_03v3 ad=1.76p pd=8.88u as=0 ps=0 w=4u l=0.28u
X35 d1_x1 D1 VDD VDD pfet_03v3 ad=0 pd=0 as=0 ps=0 w=2u l=0.28u
X36 T0 R5 VSS VSS nfet_03v3 ad=0 pd=0 as=0 ps=0 w=2u l=0.28u
X37 R10 R9 VDD VDD pfet_03v3 ad=3.52p pd=16.88u as=0 ps=0 w=8u l=0.28u
X38 OUT OB VDD VDD pfet_03v3 ad=3.52p pd=16.88u as=0 ps=0 w=8u l=0.28u
X39 D2 d2_b VDD VDD pfet_03v3 ad=1.32p pd=6.88u as=0 ps=0 w=3u l=0.28u
X40 ENB EN VSS VSS nfet_03v3 ad=0.44p pd=2.88u as=0 ps=0 w=1u l=0.28u
X41 R9 R8 VDD VDD pfet_03v3 ad=3.52p pd=16.88u as=0 ps=0 w=8u l=0.28u
X42 OB D2 VDD VDD pfet_03v3 ad=1.76p pd=8.88u as=0 ps=0 w=4u l=0.28u
X43 D2 D1 d2_x3 VSS nfet_03v3 ad=0 pd=0 as=0 ps=0 w=2u l=0.28u
X44 R10 R9 VSS VSS nfet_03v3 ad=1.76p pd=8.88u as=0 ps=0 w=4u l=0.28u
X45 OUT OB VSS VSS nfet_03v3 ad=1.76p pd=8.88u as=0 ps=0 w=4u l=0.28u
X46 R8 R7 VDD VDD pfet_03v3 ad=3.52p pd=16.88u as=0 ps=0 w=8u l=0.28u
X47 d2_x2 D1 VSS VSS nfet_03v3 ad=0 pd=0 as=0 ps=0 w=2u l=0.28u
X48 d1_x3 d1_b VSS VSS nfet_03v3 ad=0 pd=0 as=0 ps=0 w=2u l=0.28u
X49 R9 R8 VSS VSS nfet_03v3 ad=1.76p pd=8.88u as=0 ps=0 w=4u l=0.28u
X50 OB D2 VSS VSS nfet_03v3 ad=0.88p pd=4.88u as=0 ps=0 w=2u l=0.28u
X51 tap_m R5 VDD VDD pfet_03v3 ad=3.52p pd=17.76u as=0 ps=0 w=4u l=0.28u
X52 d2_x1 D2 VDD VDD pfet_03v3 ad=0 pd=0 as=0 ps=0 w=2u l=0.28u
X53 en_m EN VSS VSS nfet_03v3 ad=0 pd=0 as=0 ps=0 w=4u l=0.28u
C0 R9 d2_a 0.01402f
C1 OUT VDD 3.13904f
C2 R2 R6 0.72389f
C3 d1_a d2_b 0.12182f
C4 R1 ENB 0.00206f
C5 R1 EN 0.03644f
C6 R9 R6 0.11772f
C7 R3 R10 1.21073f
C8 R7 D2 0.0599f
C9 D2 d1_x3 0
C10 d2_x2 d2_a 0.13003f
C11 D2 R5 0.17777f
C12 R4 R2 0.56145f
C13 d1_x1 T0 0.13047f
C14 d1_x1 D1 0.02152f
C15 d2_x2 d2_x3 0.58019f
C16 VDD T0 4.2188f
C17 R9 R4 0.21157f
C18 R10 ENB 0.10705f
C19 VDD D1 6.40788f
C20 R10 EN 0.10857f
C21 R7 R5 0.17457f
C22 en_m R2 0.00879f
C23 D2 R8 0
C24 R3 R0 0.03978f
C25 VDD d2_a 1.60794f
C26 d1_x1 d1_b 0.00516f
C27 R7 R8 2.51554f
C28 d1_x1 d2_x3 0.04597f
C29 D2 tap_m 0.02943f
C30 VDD d1_b 3.28052f
C31 VDD d2_x3 1.77539f
C32 R5 R8 0.28351f
C33 R10 T0 0.26965f
C34 VDD R6 4.36532f
C35 R10 D1 1.75164f
C36 EN R0 0.47955f
C37 R3 d1_a 0
C38 R5 tap_m 0.04523f
C39 VDD d2_x1 1.67597f
C40 OB ENB 0.12111f
C41 D2 R2 0
C42 R4 VDD 5.05266f
C43 R1 R6 0
C44 d1_a d1_x2 0.12955f
C45 d2_b d1_x2 0
C46 OUT OB 0.41448f
C47 d1_a ENB 0.32186f
C48 R10 d2_a 0.1826f
C49 R7 R9 1.55261f
C50 d2_b ENB 1.57207f
C51 en_m VDD 0.01871f
C52 R10 d1_b 0.41515f
C53 R5 R2 1.47504f
C54 R1 R4 0.59524f
C55 R9 R5 0.30213f
C56 R10 R6 0.20984f
C57 OUT d2_b 0.00234f
C58 d2_x2 D2 0.12647f
C59 R1 en_m 0.02002f
C60 OB T0 0.41126f
C61 R4 R10 3.26749f
C62 R9 R8 1.49855f
C63 d1_a T0 1.70215f
C64 d1_a D1 0.29005f
C65 d2_b T0 0.35f
C66 d2_b D1 0.63013f
C67 en_m R10 0.03909f
C68 D2 d1_x1 0.0011f
C69 D2 VDD 6.7283f
C70 R7 VDD 4.5298f
C71 OB d2_x3 0.23191f
C72 d1_x3 VDD 0.41008f
C73 R5 d1_x1 0.00408f
C74 R1 D2 0
C75 R5 VDD 5.36767f
C76 d2_b d2_a 0.3019f
C77 R9 R2 0.00481f
C78 d1_a d1_b 0.04555f
C79 R4 R0 0
C80 R3 ENB 0.00489f
C81 d1_a d2_x3 1.69879f
C82 d2_b d1_b 1.10657f
C83 R3 EN 0
C84 d2_b d2_x3 0.11168f
C85 d1_x2 ENB 0.06722f
C86 en_m R0 0.97903f
C87 R1 R5 0.24312f
C88 R10 D2 0.32493f
C89 VDD R8 5.33275f
C90 EN ENB 0.04886f
C91 d2_b d2_x1 0.33295f
C92 R7 R10 0.92112f
C93 d1_x1 tap_m 0.00516f
C94 OUT ENB 0.00187f
C95 R10 d1_x3 0
C96 OUT EN 1.9884f
C97 VDD tap_m 2.47011f
C98 R10 R5 1.09781f
C99 R3 T0 0
C100 R3 D1 0
C101 T0 d1_x2 0.06002f
C102 D1 d1_x2 0.00654f
C103 VDD R2 4.30249f
C104 T0 ENB 3.32134f
C105 T0 EN 0
C106 D1 ENB 0.21835f
C107 R10 R8 0.11691f
C108 R9 VDD 4.9537f
C109 OB D2 1.13467f
C110 R1 R2 1.74688f
C111 R5 R0 0.08205f
C112 R3 R6 0.31843f
C113 d1_b d1_x2 0.83086f
C114 d2_x2 VDD 0.0101f
C115 d1_a D2 0.94388f
C116 d1_x2 d2_x3 0.48867f
C117 d2_a ENB 0.00788f
C118 D2 d2_b 0.95288f
C119 d1_b ENB 0.09846f
C120 d2_x3 ENB 0.14776f
C121 R10 R2 0.24077f
C122 T0 D1 0.77702f
C123 R6 ENB 0.09575f
C124 R3 R4 1.22147f
C125 d1_x3 d2_b 0
C126 R9 R10 0.78007f
C127 d1_a R5 0.07034f
C128 OUT d2_x3 0.1392f
C129 R5 d2_b 0.03029f
C130 d1_x1 VDD 1.91584f
C131 R4 ENB 0.00186f
C132 d2_x2 R10 0.00415f
C133 OB tap_m 0
C134 D1 d2_a 0.62941f
C135 T0 d1_b 0.71397f
C136 D1 d1_b 0.95894f
C137 T0 d2_x3 0.15671f
C138 en_m EN 0.41453f
C139 D1 d2_x3 0.28382f
C140 R1 VDD 5.47845f
C141 R2 R0 0.25681f
C142 D1 R6 0
C143 d2_b tap_m 0
C144 D1 d2_x1 0.17451f
C145 R4 T0 0
C146 R3 D2 0
C147 R4 D1 0
C148 R10 VDD 6.69574f
C149 d2_a d2_x3 0.15933f
C150 d1_a R2 0
C151 d1_b d2_x3 0.10379f
C152 R7 R3 0.00587f
C153 D2 d1_x2 0
C154 d1_b R6 0
C155 D2 ENB 2.15493f
C156 R3 R5 3.93102f
C157 R1 R10 0.76836f
C158 d2_a d2_x1 0.73184f
C159 d1_x3 d1_x2 0.10008f
C160 d1_b d2_x1 0
C161 R7 ENB 0.00713f
C162 R5 d1_x2 0.05716f
C163 OUT D2 0.12547f
C164 R4 d1_b 0
C165 d1_x3 ENB 0
C166 d2_x2 d2_b 0.80022f
C167 R5 ENB 3.80451f
C168 R5 EN 0.02809f
C169 R4 R6 0.95074f
C170 VDD R0 7.25574f
C171 OB d1_x1 0
C172 OB VDD 3.04813f
C173 D2 T0 1.11423f
C174 D2 D1 2.24592f
C175 R1 R0 0.81273f
C176 d1_a d1_x1 0.81727f
C177 d1_x1 d2_b 0
C178 d1_a VDD 1.10926f
C179 R7 D1 0
C180 d1_x3 T0 0.02161f
C181 VDD d2_b 2.95452f
C182 d1_x3 D1 0.87352f
C183 tap_m ENB 0.0578f
C184 R5 T0 0.30277f
C185 tap_m EN 0
C186 R5 D1 0.16421f
C187 R3 R2 1.61697f
C188 R10 R0 1.32632f
C189 R9 R3 0.0395f
C190 D2 d2_a 0.20287f
C191 D2 d1_b 0.66565f
C192 D2 d2_x3 2.74882f
C193 R2 ENB 0.00186f
C194 D2 R6 0
C195 R2 EN 0
C196 R8 D1 0
C197 d1_x3 d1_b 0.0419f
C198 d1_x3 d2_x3 0.48905f
C199 R5 d1_b 0.42589f
C200 R7 R6 1.20677f
C201 d1_a R10 0
C202 D2 d2_x1 0.02193f
C203 R5 d2_x3 0.10598f
C204 R10 d2_b 0
C205 tap_m T0 0.82051f
C206 tap_m D1 0
C207 R4 D2 0
C208 R5 R6 1.988f
C209 R7 R4 0.26987f
C210 R8 d2_a 0.19086f
C211 R4 R5 1.83236f
C212 D1 R2 0
C213 R8 R6 0.8274f
C214 R3 VDD 4.4349f
C215 R9 D1 0
C216 tap_m d2_x3 0
C217 VDD d1_x2 0.41008f
C218 d1_x1 ENB 0.13074f
C219 R4 R8 0.18823f
C220 VDD ENB 3.21024f
C221 R3 R1 0.30811f
C222 OB d1_a 0.05123f
C223 VDD EN 3.55635f
C224 OB d2_b 0.66038f
C225 d2_x2 D1 0.02743f
C226 EN VSS 13.82087f
C227 OB VSS 5.42905f $ **FLOATING
C228 R9 VSS 6.2252f $ **FLOATING
C229 OUT VSS 4.61859f
C230 d2_x3 VSS 5.51215f $ **FLOATING
C231 ENB VSS 9.05676f $ **FLOATING
C232 d1_x1 VSS 0.3301f $ **FLOATING
C233 R4 VSS 4.83115f $ **FLOATING
C234 VDD VSS 0.12058p
C235 d1_x2 VSS 1.98475f $ **FLOATING
C236 R0 VSS 5.7592f $ **FLOATING
C237 en_m VSS 3.08673f $ **FLOATING
C238 R10 VSS 7.09012f $ **FLOATING
C239 d2_a VSS 4.3438f $ **FLOATING
C240 D2 VSS 9.29065f $ **FLOATING
C241 R5 VSS 8.92004f $ **FLOATING
C242 d1_x3 VSS 2.05664f $ **FLOATING
C243 d2_x1 VSS 0.34241f $ **FLOATING
C244 R6 VSS 7.31255f $ **FLOATING
C245 d2_b VSS 3.78794f $ **FLOATING
C246 d2_x2 VSS 1.90762f $ **FLOATING
C247 R1 VSS 5.89594f $ **FLOATING
C248 R7 VSS 5.62301f $ **FLOATING
C249 R2 VSS 6.02221f $ **FLOATING
C250 R8 VSS 6.10905f $ **FLOATING
C251 tap_m VSS 0.57739f $ **FLOATING
C252 R3 VSS 4.88044f $ **FLOATING
C253 d1_a VSS 2.98034f $ **FLOATING
C254 D1 VSS 8.63281f $ **FLOATING
C255 T0 VSS 6.67327f $ **FLOATING
C256 d1_b VSS 3.99211f $ **FLOATING
.ends
