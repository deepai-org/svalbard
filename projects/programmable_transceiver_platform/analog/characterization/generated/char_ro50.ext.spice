* NGSPICE file created from pt_char_ro50.ext - technology: gf180mcuD

.subckt pt_char_ro50 EN OUT VDD VSS
X0 d1_b T0 VDD VDD pfet_03v3 ad=0.88p pd=4.88u as=0.88p ps=4.88u w=2u l=0.28u
X1 d1_b d1_a d1_x2 VSS nfet_03v3 ad=0.88p pd=4.88u as=0.88p ps=4.88u w=2u l=0.28u
X2 d1_a T0 d1_x1 VDD pfet_03v3 ad=0.88p pd=4.88u as=1.76p ps=9.76u w=2u l=0.28u
X3 T0 ENB VSS VSS nfet_03v3 ad=1.76p pd=9.76u as=10.12p ps=57.44u w=2u l=0.28u
X4 R0 R10 VDD VDD pfet_05v0 ad=3.52p pd=16.88u as=3.52p ps=16.88u w=8u l=0.5u
X5 D1 ENB VSS VSS nfet_03v3 ad=0.44p pd=2.88u as=0.44p ps=2.88u w=1u l=0.28u
X6 d1_a D1 VSS VSS nfet_03v3 ad=0.44p pd=2.88u as=0 ps=0 w=1u l=0.28u
X7 R7 R6 VDD VDD pfet_05v0 ad=3.52p pd=16.88u as=42.24p ps=0.20256m w=8u l=0.5u
X8 R3 R2 VSS VSS nfet_05v0 ad=1.76p pd=8.88u as=1.76p ps=8.88u w=4u l=0.6u
X9 T0 ENB tap_m VDD pfet_03v3 ad=1.76p pd=8.88u as=1.76p ps=8.88u w=4u l=0.28u
X10 R8 R7 VSS VSS nfet_05v0 ad=1.76p pd=8.88u as=19.36p ps=97.68u w=4u l=0.6u
X11 d2_x3 d2_b VSS VSS nfet_03v3 ad=1.76p pd=9.76u as=0 ps=0 w=2u l=0.28u
X12 R6 R5 VDD VDD pfet_05v0 ad=3.52p pd=16.88u as=0 ps=0 w=8u l=0.5u
X13 R2 R1 VSS VSS nfet_05v0 ad=1.76p pd=8.88u as=0 ps=0 w=4u l=0.6u
X14 R5 R4 VDD VDD pfet_05v0 ad=3.52p pd=16.88u as=0 ps=0 w=8u l=0.5u
X15 R7 R6 VSS VSS nfet_05v0 ad=1.76p pd=8.88u as=0 ps=0 w=4u l=0.6u
X16 R1 R0 VSS VSS nfet_05v0 ad=1.76p pd=8.88u as=0 ps=0 w=4u l=0.6u
X17 d2_b D1 VDD VDD pfet_03v3 ad=0.88p pd=4.88u as=14.08p ps=72.8u w=2u l=0.28u
X18 D1 d1_b VDD VDD pfet_03v3 ad=1.32p pd=6.88u as=1.32p ps=6.88u w=3u l=0.28u
X19 R2 R1 VDD VDD pfet_05v0 ad=3.52p pd=16.88u as=0 ps=0 w=8u l=0.5u
X20 d2_b d2_a d2_x2 VSS nfet_03v3 ad=0.88p pd=4.88u as=1.76p ps=9.76u w=2u l=0.28u
X21 R4 R3 VDD VDD pfet_05v0 ad=3.52p pd=16.88u as=0 ps=0 w=8u l=0.5u
X22 R6 R5 VSS VSS nfet_05v0 ad=1.76p pd=8.88u as=0 ps=0 w=4u l=0.6u
X23 d2_a D1 d2_x1 VDD pfet_03v3 ad=0.88p pd=4.88u as=1.76p ps=9.76u w=2u l=0.28u
X24 D1 T0 d1_x3 VSS nfet_03v3 ad=1.32p pd=7.76u as=1.76p ps=9.76u w=2u l=0.28u
X25 D2 ENB VSS VSS nfet_03v3 ad=1.32p pd=7.76u as=0 ps=0 w=1u l=0.28u
X26 R1 R0 VDD VDD pfet_05v0 ad=3.52p pd=16.88u as=0 ps=0 w=8u l=0.5u
X27 R5 R4 VSS VSS nfet_05v0 ad=1.76p pd=8.88u as=0 ps=0 w=4u l=0.6u
X28 d2_a D2 VSS VSS nfet_03v3 ad=0.44p pd=2.88u as=0 ps=0 w=1u l=0.28u
X29 R3 R2 VDD VDD pfet_05v0 ad=3.52p pd=16.88u as=0 ps=0 w=8u l=0.5u
X30 R0 R10 en_m VSS nfet_05v0 ad=1.76p pd=8.88u as=3.52p ps=17.76u w=4u l=0.6u
X31 d1_x2 T0 VSS VSS nfet_03v3 ad=1.76p pd=9.76u as=0 ps=0 w=2u l=0.28u
X32 ENB EN VDD VDD pfet_03v3 ad=0.88p pd=4.88u as=0 ps=0 w=2u l=0.28u
X33 R0 EN VDD VDD pfet_05v0 ad=7.04p pd=33.76u as=0 ps=0 w=8u l=0.5u
X34 R4 R3 VSS VSS nfet_05v0 ad=1.76p pd=8.88u as=0 ps=0 w=4u l=0.6u
X35 d1_x1 D1 VDD VDD pfet_03v3 ad=0 pd=0 as=0 ps=0 w=2u l=0.28u
X36 T0 R5 VSS VSS nfet_03v3 ad=0 pd=0 as=0 ps=0 w=2u l=0.28u
X37 R10 R9 VDD VDD pfet_05v0 ad=3.52p pd=16.88u as=0 ps=0 w=8u l=0.5u
X38 OUT OB VDD VDD pfet_03v3 ad=3.52p pd=16.88u as=3.52p ps=16.88u w=8u l=0.28u
X39 D2 d2_b VDD VDD pfet_03v3 ad=1.32p pd=6.88u as=0 ps=0 w=3u l=0.28u
X40 ENB EN VSS VSS nfet_03v3 ad=0.44p pd=2.88u as=0 ps=0 w=1u l=0.28u
X41 R9 R8 VDD VDD pfet_05v0 ad=3.52p pd=16.88u as=0 ps=0 w=8u l=0.5u
X42 OB D2 VDD VDD pfet_03v3 ad=1.76p pd=8.88u as=0 ps=0 w=4u l=0.28u
X43 D2 D1 d2_x3 VSS nfet_03v3 ad=0 pd=0 as=0 ps=0 w=2u l=0.28u
X44 R10 R9 VSS VSS nfet_05v0 ad=1.76p pd=8.88u as=0 ps=0 w=4u l=0.6u
X45 OUT OB VSS VSS nfet_03v3 ad=1.76p pd=8.88u as=1.76p ps=8.88u w=4u l=0.28u
X46 R8 R7 VDD VDD pfet_05v0 ad=3.52p pd=16.88u as=0 ps=0 w=8u l=0.5u
X47 d2_x2 D1 VSS VSS nfet_03v3 ad=0 pd=0 as=0 ps=0 w=2u l=0.28u
X48 d1_x3 d1_b VSS VSS nfet_03v3 ad=0 pd=0 as=0 ps=0 w=2u l=0.28u
X49 R9 R8 VSS VSS nfet_05v0 ad=1.76p pd=8.88u as=0 ps=0 w=4u l=0.6u
X50 OB D2 VSS VSS nfet_03v3 ad=0.88p pd=4.88u as=0 ps=0 w=2u l=0.28u
X51 tap_m R5 VDD VDD pfet_03v3 ad=3.52p pd=17.76u as=0 ps=0 w=4u l=0.28u
X52 d2_x1 D2 VDD VDD pfet_03v3 ad=0 pd=0 as=0 ps=0 w=2u l=0.28u
X53 en_m EN VSS VSS nfet_05v0 ad=0 pd=0 as=0 ps=0 w=4u l=0.6u
C0 ENB R10 0.10817f
C1 d1_x2 d2_b 0
C2 d1_x2 d2_x3 0.48867f
C3 D1 R4 0
C4 R7 R10 0.13611f
C5 en_m EN 0.47401f
C6 OUT EN 1.9884f
C7 R5 R3 1.60536f
C8 R5 R6 0.32465f
C9 D1 d1_x3 0.85682f
C10 D1 VDD 6.4634f
C11 tap_m EN 0
C12 D1 d2_b 0.62994f
C13 D1 d2_x3 0.28379f
C14 d1_b R5 0.39803f
C15 T0 EN 0
C16 ENB EN 0.04886f
C17 D1 R10 0.01907f
C18 R2 R0 0
C19 d2_a R6 0.01553f
C20 D2 R5 0.46038f
C21 tap_m R5 0.04523f
C22 D2 R3 0.21038f
C23 d1_x1 R5 0.00408f
C24 D2 R6 0.11427f
C25 d1_a R5 0.33578f
C26 T0 R5 0.29353f
C27 R1 R0 0.63105f
C28 R2 R4 0.0046f
C29 R8 d2_a 0.09786f
C30 R2 R1 1.00403f
C31 T0 R3 0.00411f
C32 d1_a R3 0.02381f
C33 ENB R5 4.79787f
C34 d2_x1 VDD 1.66093f
C35 D2 d1_b 0.60293f
C36 ENB R3 0.10936f
C37 d2_x1 d2_b 0.33295f
C38 ENB R6 0.29679f
C39 VDD R0 6.94947f
C40 R7 R5 0
C41 d1_x1 d1_b 0.00516f
C42 D2 OUT 0.12268f
C43 d2_a D2 0.25583f
C44 d1_b d1_a 0.04142f
C45 T0 d1_b 0.69425f
C46 VDD R2 3.81019f
C47 d1_x2 R5 0.05552f
C48 R7 R6 1.00016f
C49 ENB d1_b 0.13465f
C50 d2_x2 d2_a 0.13003f
C51 tap_m D2 0.01724f
C52 VDD R4 3.61404f
C53 ENB OUT 0.00187f
C54 ENB d2_a 0.00954f
C55 R10 R0 1.35693f
C56 d1_x1 D2 0.00212f
C57 VDD R1 4.12342f
C58 d1_x1 tap_m 0.00516f
C59 d2_x2 D2 0.12647f
C60 D2 d1_a 1.23424f
C61 T0 D2 1.01247f
C62 R10 R2 0.24345f
C63 R8 R7 1.01563f
C64 T0 tap_m 0.82051f
C65 VDD OB 3.04813f
C66 d1_x2 d1_b 0.8166f
C67 R7 d2_a 0.13341f
C68 d2_b OB 0.66038f
C69 ENB D2 0.48978f
C70 T0 d1_x1 0.12519f
C71 d1_x1 d1_a 0.81318f
C72 OB d2_x3 0.22912f
C73 tap_m ENB 0.0578f
C74 T0 d1_a 2.65645f
C75 VDD d1_x3 0.41008f
C76 D1 R5 0.15557f
C77 d1_x1 ENB 0.11834f
C78 R10 R4 2.36032f
C79 d1_x3 d2_b 0
C80 d1_x3 d2_x3 0.48905f
C81 R10 R1 0.26211f
C82 ENB d1_a 0.28203f
C83 T0 ENB 2.47449f
C84 VDD d2_b 2.94924f
C85 R7 D2 0.03289f
C86 D1 R3 0
C87 VDD d2_x3 1.7437f
C88 d1_x2 D2 0
C89 d2_b d2_x3 0.10851f
C90 R9 VDD 3.84383f
C91 d1_x2 d1_a 0.1295f
C92 T0 d1_x2 0.04667f
C93 VDD R10 5.57148f
C94 D1 d1_b 0.96355f
C95 R7 ENB 0.01376f
C96 R10 d2_x3 0
C97 ENB d1_x2 0.06055f
C98 R0 EN 0.4083f
C99 D1 d2_a 0.67735f
C100 R9 R10 0.62999f
C101 D1 D2 2.21948f
C102 D1 tap_m 0
C103 D1 d1_x1 0.02152f
C104 R1 EN 0.01267f
C105 D1 d2_x2 0.02743f
C106 D1 d1_a 0.21709f
C107 D1 T0 0.48417f
C108 D1 ENB 0.21955f
C109 R5 R0 0.11383f
C110 R2 R5 1.54501f
C111 VDD EN 3.3106f
C112 R2 R3 0.64913f
C113 d2_x1 d1_b 0.00306f
C114 D1 d1_x2 0.00654f
C115 R5 R4 1.07865f
C116 R1 R5 0.30774f
C117 d2_x1 d2_a 0.73184f
C118 R3 R4 1.17155f
C119 en_m R0 0.69319f
C120 R6 R4 0.01487f
C121 R2 d1_b 0.00365f
C122 R1 R3 0
C123 R10 EN 0.12688f
C124 d2_x1 D2 0.02193f
C125 VDD R5 5.8933f
C126 d1_b R4 0.00684f
C127 d2_b R5 0.03233f
C128 d2_x3 R5 0.10095f
C129 VDD R3 3.95833f
C130 VDD R6 4.00679f
C131 en_m R1 0.0196f
C132 D2 R2 0.29828f
C133 OB OUT 0.41486f
C134 R2 d1_a 0.23999f
C135 d1_x3 d1_b 0.05495f
C136 T0 R2 0.1552f
C137 R10 R5 0.92713f
C138 ENB R0 0.01483f
C139 VDD d1_b 3.39072f
C140 D2 R4 0.14934f
C141 en_m VDD 0.0305f
C142 D2 R1 0.11408f
C143 R8 VDD 4.15462f
C144 ENB R2 0.36629f
C145 R10 R3 0.53599f
C146 d2_b d1_b 0.85544f
C147 R10 R6 0.14545f
C148 d2_x3 d1_b 0.10412f
C149 VDD OUT 3.13904f
C150 OB D2 1.0649f
C151 VDD d2_a 1.67137f
C152 tap_m OB 0
C153 T0 R4 0
C154 d2_b OUT 0.00234f
C155 d1_a R1 0.02816f
C156 d2_b d2_a 0.30171f
C157 d2_x3 OUT 0.13603f
C158 d2_a d2_x3 0.15914f
C159 d1_x1 OB 0
C160 d1_x3 D2 0
C161 ENB R4 0.09913f
C162 OB d1_a 0.05123f
C163 T0 OB 0.41158f
C164 VDD D2 6.61967f
C165 R10 d1_b 0.3399f
C166 ENB R1 0.1952f
C167 R9 R8 1.01433f
C168 VDD tap_m 2.47011f
C169 R8 R10 0.15916f
C170 en_m R10 0.06801f
C171 d2_b D2 0.97251f
C172 ENB OB 0.12111f
C173 D2 d2_x3 3.64184f
C174 tap_m d2_b 0
C175 d1_x1 VDD 1.91584f
C176 T0 d1_x3 0.02154f
C177 tap_m d2_x3 0
C178 d2_a R10 0.19184f
C179 VDD d2_x2 0.0101f
C180 VDD d1_a 1.07208f
C181 T0 VDD 4.23099f
C182 d1_x1 d2_b 0
C183 d1_x1 d2_x3 0.04597f
C184 ENB d1_x3 0
C185 d2_x2 d2_b 0.80022f
C186 d2_b d1_a 0.11042f
C187 T0 d2_b 0.31086f
C188 d2_x2 d2_x3 0.58019f
C189 d2_x3 d1_a 1.6947f
C190 T0 d2_x3 0.15091f
C191 VDD ENB 5.19635f
C192 D1 d2_x1 0.19794f
C193 R10 D2 0.33897f
C194 ENB d2_b 1.63404f
C195 ENB d2_x3 0.1439f
C196 R5 EN 0.09687f
C197 VDD R7 4.15508f
C198 d1_x2 d1_x3 0.10008f
C199 T0 R10 0.04005f
C200 D1 R2 0
C201 VDD d1_x2 0.41008f
C202 EN VSS 13.35399f
C203 tap_m VSS 0.56637f $ **FLOATING
C204 OB VSS 5.45338f $ **FLOATING
C205 R9 VSS 5.77637f $ **FLOATING
C206 d2_x2 VSS 1.91293f $ **FLOATING
C207 OUT VSS 4.61178f
C208 d2_x3 VSS 5.48051f $ **FLOATING
C209 ENB VSS 9.24512f $ **FLOATING
C210 T0 VSS 7.7438f $ **FLOATING
C211 d1_x1 VSS 0.31907f $ **FLOATING
C212 R4 VSS 5.02711f $ **FLOATING
C213 d1_x2 VSS 1.98548f $ **FLOATING
C214 R0 VSS 4.48078f $ **FLOATING
C215 en_m VSS 2.9085f $ **FLOATING
C216 R10 VSS 7.61128f $ **FLOATING
C217 d2_a VSS 4.61066f $ **FLOATING
C218 D2 VSS 9.36244f $ **FLOATING
C219 R5 VSS 7.32479f $ **FLOATING
C220 d1_x3 VSS 2.05737f $ **FLOATING
C221 d2_x1 VSS 0.33139f $ **FLOATING
C222 R6 VSS 5.85209f $ **FLOATING
C223 d2_b VSS 3.7811f $ **FLOATING
C224 R1 VSS 5.24617f $ **FLOATING
C225 R7 VSS 5.15075f $ **FLOATING
C226 R2 VSS 4.89641f $ **FLOATING
C227 R8 VSS 5.16513f $ **FLOATING
C228 R3 VSS 4.61476f $ **FLOATING
C229 d1_a VSS 3.40628f $ **FLOATING
C230 D1 VSS 11.21239f $ **FLOATING
C231 VDD VSS 0.11936p
C232 d1_b VSS 4.42983f $ **FLOATING
.ends
