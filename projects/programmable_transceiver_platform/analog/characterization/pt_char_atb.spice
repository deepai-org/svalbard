* generated by structures.py; do not edit
.subckt pt_char_atb RN_LNA RP_LNA RN_MIX RP_MIX RN_SMP RP_SMP RN_DRV RP_DRV RES_A RES_B MIM_A MIM_B VSS
XMRN_LNA_0 RN_LNA RN_LNA VSS VSS nfet_03v3 w=5.0u l=0.5u
XMRN_LNA_1 RN_LNA RN_LNA VSS VSS nfet_03v3 w=5.0u l=0.5u
XMRP_LNA_0 VSS VSS RP_LNA RP_LNA pfet_03v3 w=5.0u l=0.28u
XMRP_LNA_1 VSS VSS RP_LNA RP_LNA pfet_03v3 w=5.0u l=0.28u
XMRN_MIX_0 RN_MIX RN_MIX VSS VSS nfet_03v3 w=5.0u l=0.28u
XMRN_MIX_1 RN_MIX RN_MIX VSS VSS nfet_03v3 w=5.0u l=0.28u
XMRP_MIX_0 VSS VSS RP_MIX RP_MIX pfet_03v3 w=20.0u l=1.0u
XMRN_SMP_0 RN_SMP RN_SMP VSS VSS nfet_03v3 w=8.0u l=0.28u
XMRP_SMP_0 VSS VSS RP_SMP RP_SMP pfet_03v3 w=10.0u l=0.28u
XMRN_DRV_0 RN_DRV RN_DRV VSS VSS nfet_03v3 w=20.0u l=0.5u
XMRP_DRV_0 VSS VSS RP_DRV RP_DRV pfet_03v3 w=20.0u l=0.28u
XRA0_0 RES_A ra1 VSS ppolyf_u_1k r_width=2.0u r_length=10.0u
XRB0_0 RES_B rb1 VSS ppolyf_u_1k r_width=2.0u r_length=10.0u
XRB1_0 rb1 rb2 VSS ppolyf_u_1k r_width=2.0u r_length=10.0u
XRA1_0 ra1 ra2 VSS ppolyf_u_1k r_width=2.0u r_length=10.0u
XRA2_0 ra2 ra3 VSS ppolyf_u_1k r_width=2.0u r_length=10.0u
XRB2_0 rb2 rb3 VSS ppolyf_u_1k r_width=2.0u r_length=10.0u
XRB3_0 rb3 VSS VSS ppolyf_u_1k r_width=2.0u r_length=10.0u
XRA3_0 ra3 VSS VSS ppolyf_u_1k r_width=2.0u r_length=10.0u
XCA0_0 MIM_A VSS cap_mim_2f0_m4m5_noshield c_width=40.0u c_length=40.0u
XCB1_0 MIM_B VSS cap_mim_2f0_m4m5_noshield c_width=40.0u c_length=40.0u
XCB2_0 MIM_B VSS cap_mim_2f0_m4m5_noshield c_width=40.0u c_length=40.0u
XCA3_0 MIM_A VSS cap_mim_2f0_m4m5_noshield c_width=40.0u c_length=40.0u
.ends
