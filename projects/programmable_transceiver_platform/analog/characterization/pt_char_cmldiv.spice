* generated by speed.py; do not edit
.subckt pt_char_cmldiv EN OUT BIAS VDD VSS
XN1_0 ENB EN VSS VSS nfet_03v3 w=1.0u l=0.28u
XP2_0 ENB EN VDD VDD pfet_03v3 w=2.0u l=0.28u
XP3_0 BT ENB VDD VDD pfet_03v3 w=4.0u l=0.28u
XR4_0 BT BIAS VSS ppolyf_u_1k r_width=1.0u r_length=36.0u
XN5_0 BIAS BIAS VSS VSS nfet_03v3 w=1.0u l=0.5u
XN6_0 BIAS ENB VSS VSS nfet_03v3 w=1.0u l=0.28u
XN7_0 s0M_t BIAS VSS VSS nfet_03v3 w=10.0u l=0.5u
XN8_0 s0M_a VDD s0M_t VSS nfet_03v3 w=10.0u l=0.28u
XN9_0 s0M_h VDD s0M_t VSS nfet_03v3 w=10.0u l=0.28u
XN10_0 s0_mb S0B s0M_a VSS nfet_03v3 w=10.0u l=0.28u
XN11_0 s0_m S0 s0M_a VSS nfet_03v3 w=10.0u l=0.28u
XN12_0 s0_mb s0_m s0M_h VSS nfet_03v3 w=10.0u l=0.28u
XN13_0 s0_m s0_mb s0M_h VSS nfet_03v3 w=10.0u l=0.28u
XR14_0 VDD s0_m VSS ppolyf_u_1k r_width=1.0u r_length=1.8u
XR15_0 VDD s0_mb VSS ppolyf_u_1k r_width=1.0u r_length=1.8u
XN16_0 s0S_t BIAS VSS VSS nfet_03v3 w=10.0u l=0.5u
XN17_0 s0S_a VDD s0S_t VSS nfet_03v3 w=10.0u l=0.28u
XN18_0 s0S_h VDD s0S_t VSS nfet_03v3 w=10.0u l=0.28u
XN19_0 S0B s0_m s0S_a VSS nfet_03v3 w=10.0u l=0.28u
XN20_0 S0 s0_mb s0S_a VSS nfet_03v3 w=10.0u l=0.28u
XN21_0 S0B S0 s0S_h VSS nfet_03v3 w=10.0u l=0.28u
XN22_0 S0 S0B s0S_h VSS nfet_03v3 w=10.0u l=0.28u
XR23_0 VDD S0 VSS ppolyf_u_1k r_width=1.0u r_length=1.8u
XR24_0 VDD S0B VSS ppolyf_u_1k r_width=1.0u r_length=1.8u
XN25_0 s1M_t BIAS VSS VSS nfet_03v3 w=10.0u l=0.5u
XN26_0 s1M_a S0 s1M_t VSS nfet_03v3 w=10.0u l=0.28u
XN27_0 s1M_h S0B s1M_t VSS nfet_03v3 w=10.0u l=0.28u
XN28_0 s1_mb S1B s1M_a VSS nfet_03v3 w=10.0u l=0.28u
XN29_0 s1_m S1 s1M_a VSS nfet_03v3 w=10.0u l=0.28u
XN30_0 s1_mb s1_m s1M_h VSS nfet_03v3 w=10.0u l=0.28u
XN31_0 s1_m s1_mb s1M_h VSS nfet_03v3 w=10.0u l=0.28u
XR32_0 VDD s1_m VSS ppolyf_u_1k r_width=1.0u r_length=1.8u
XR33_0 VDD s1_mb VSS ppolyf_u_1k r_width=1.0u r_length=1.8u
XN34_0 s1S_t BIAS VSS VSS nfet_03v3 w=10.0u l=0.5u
XN35_0 s1S_a S0B s1S_t VSS nfet_03v3 w=10.0u l=0.28u
XN36_0 s1S_h S0 s1S_t VSS nfet_03v3 w=10.0u l=0.28u
XN37_0 S1B s1_m s1S_a VSS nfet_03v3 w=10.0u l=0.28u
XN38_0 S1 s1_mb s1S_a VSS nfet_03v3 w=10.0u l=0.28u
XN39_0 S1B S1 s1S_h VSS nfet_03v3 w=10.0u l=0.28u
XN40_0 S1 S1B s1S_h VSS nfet_03v3 w=10.0u l=0.28u
XR41_0 VDD S1 VSS ppolyf_u_1k r_width=1.0u r_length=1.8u
XR42_0 VDD S1B VSS ppolyf_u_1k r_width=1.0u r_length=1.8u
XN43_0 s2M_t BIAS VSS VSS nfet_03v3 w=10.0u l=0.5u
XN44_0 s2M_a S1 s2M_t VSS nfet_03v3 w=10.0u l=0.28u
XN45_0 s2M_h S1B s2M_t VSS nfet_03v3 w=10.0u l=0.28u
XN46_0 s2_mb S2B s2M_a VSS nfet_03v3 w=10.0u l=0.28u
XN47_0 s2_m S2 s2M_a VSS nfet_03v3 w=10.0u l=0.28u
XN48_0 s2_mb s2_m s2M_h VSS nfet_03v3 w=10.0u l=0.28u
XN49_0 s2_m s2_mb s2M_h VSS nfet_03v3 w=10.0u l=0.28u
XR50_0 VDD s2_m VSS ppolyf_u_1k r_width=1.0u r_length=1.8u
XR51_0 VDD s2_mb VSS ppolyf_u_1k r_width=1.0u r_length=1.8u
XN52_0 s2S_t BIAS VSS VSS nfet_03v3 w=10.0u l=0.5u
XN53_0 s2S_a S1B s2S_t VSS nfet_03v3 w=10.0u l=0.28u
XN54_0 s2S_h S1 s2S_t VSS nfet_03v3 w=10.0u l=0.28u
XN55_0 S2B s2_m s2S_a VSS nfet_03v3 w=10.0u l=0.28u
XN56_0 S2 s2_mb s2S_a VSS nfet_03v3 w=10.0u l=0.28u
XN57_0 S2B S2 s2S_h VSS nfet_03v3 w=10.0u l=0.28u
XN58_0 S2 S2B s2S_h VSS nfet_03v3 w=10.0u l=0.28u
XR59_0 VDD S2 VSS ppolyf_u_1k r_width=1.0u r_length=1.8u
XR60_0 VDD S2B VSS ppolyf_u_1k r_width=1.0u r_length=1.8u
XN61_0 CT BIAS VSS VSS nfet_03v3 w=10.0u l=0.5u
XN62_0 CX S2 CT VSS nfet_03v3 w=10.0u l=0.28u
XN63_0 CY S2B CT VSS nfet_03v3 w=10.0u l=0.28u
XP64_0 CX CX VDD VDD pfet_03v3 w=8.0u l=0.28u
XP65_0 CY CX VDD VDD pfet_03v3 w=8.0u l=0.28u
XN66_0 C1 CY VSS VSS nfet_03v3 w=2.0u l=0.28u
XP67_0 C1 CY VDD VDD pfet_03v3 w=4.0u l=0.28u
XN68_0 C2 C1 VSS VSS nfet_03v3 w=2.0u l=0.28u
XN69_0 C2 ENB VSS VSS nfet_03v3 w=2.0u l=0.28u
XP70_0 cg_m C1 VDD VDD pfet_03v3 w=4.0u l=0.28u
XP71_0 C2 ENB cg_m VDD pfet_03v3 w=4.0u l=0.28u
XP72_0 d1_x1 D1 VDD VDD pfet_03v3 w=2.0u l=0.28u
XP73_0 d1_a C2 d1_x1 VDD pfet_03v3 w=2.0u l=0.28u
XN74_0 d1_a D1 VSS VSS nfet_03v3 w=1.0u l=0.28u
XP75_0 d1_b C2 VDD VDD pfet_03v3 w=2.0u l=0.28u
XN76_0 d1_b d1_a d1_x2 VSS nfet_03v3 w=2.0u l=0.28u
XN77_0 d1_x2 C2 VSS VSS nfet_03v3 w=2.0u l=0.28u
XP78_0 D1 d1_b VDD VDD pfet_03v3 w=3.0u l=0.28u
XN79_0 D1 C2 d1_x3 VSS nfet_03v3 w=2.0u l=0.28u
XN80_0 d1_x3 d1_b VSS VSS nfet_03v3 w=2.0u l=0.28u
XN81_0 D1 ENB VSS VSS nfet_03v3 w=1.0u l=0.28u
XN82_0 OB D1 VSS VSS nfet_03v3 w=2.0u l=0.28u
XP83_0 OB D1 VDD VDD pfet_03v3 w=4.0u l=0.28u
XN84_0 OUT OB VSS VSS nfet_03v3 w=4.0u l=0.28u
XP85_0 OUT OB VDD VDD pfet_03v3 w=8.0u l=0.28u
.ends
