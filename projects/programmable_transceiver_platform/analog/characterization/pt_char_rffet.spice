* generated by rffet.py; do not edit
.subckt pt_char_rffet G D GND
XM0 D G GND GND nfet_03v3 w=2u l=0.28u
XM1 D G GND GND nfet_03v3 w=2u l=0.28u
XM2 D G GND GND nfet_03v3 w=2u l=0.28u
XM3 D G GND GND nfet_03v3 w=2u l=0.28u
XM4 D G GND GND nfet_03v3 w=2u l=0.28u
.ends
