* generated by speed.py; do not edit
.subckt pt_char_ro33 EN OUT VDD VSS
XN1_0 R0 R10 en_m VSS nfet_03v3 w=4.0u l=0.28u
XN2_0 en_m EN VSS VSS nfet_03v3 w=4.0u l=0.28u
XP3_0 R0 R10 VDD VDD pfet_03v3 w=8.0u l=0.28u
XP4_0 R0 EN VDD VDD pfet_03v3 w=8.0u l=0.28u
XN5_0 R1 R0 VSS VSS nfet_03v3 w=4.0u l=0.28u
XP6_0 R1 R0 VDD VDD pfet_03v3 w=8.0u l=0.28u
XN7_0 R2 R1 VSS VSS nfet_03v3 w=4.0u l=0.28u
XP8_0 R2 R1 VDD VDD pfet_03v3 w=8.0u l=0.28u
XN9_0 R3 R2 VSS VSS nfet_03v3 w=4.0u l=0.28u
XP10_0 R3 R2 VDD VDD pfet_03v3 w=8.0u l=0.28u
XN11_0 R4 R3 VSS VSS nfet_03v3 w=4.0u l=0.28u
XP12_0 R4 R3 VDD VDD pfet_03v3 w=8.0u l=0.28u
XN13_0 R5 R4 VSS VSS nfet_03v3 w=4.0u l=0.28u
XP14_0 R5 R4 VDD VDD pfet_03v3 w=8.0u l=0.28u
XN15_0 R6 R5 VSS VSS nfet_03v3 w=4.0u l=0.28u
XP16_0 R6 R5 VDD VDD pfet_03v3 w=8.0u l=0.28u
XN17_0 R7 R6 VSS VSS nfet_03v3 w=4.0u l=0.28u
XP18_0 R7 R6 VDD VDD pfet_03v3 w=8.0u l=0.28u
XN19_0 R8 R7 VSS VSS nfet_03v3 w=4.0u l=0.28u
XP20_0 R8 R7 VDD VDD pfet_03v3 w=8.0u l=0.28u
XN21_0 R9 R8 VSS VSS nfet_03v3 w=4.0u l=0.28u
XP22_0 R9 R8 VDD VDD pfet_03v3 w=8.0u l=0.28u
XN23_0 R10 R9 VSS VSS nfet_03v3 w=4.0u l=0.28u
XP24_0 R10 R9 VDD VDD pfet_03v3 w=8.0u l=0.28u
XN25_0 ENB EN VSS VSS nfet_03v3 w=1.0u l=0.28u
XP26_0 ENB EN VDD VDD pfet_03v3 w=2.0u l=0.28u
XN27_0 T0 R5 VSS VSS nfet_03v3 w=2.0u l=0.28u
XN28_0 T0 ENB VSS VSS nfet_03v3 w=2.0u l=0.28u
XP29_0 tap_m R5 VDD VDD pfet_03v3 w=4.0u l=0.28u
XP30_0 T0 ENB tap_m VDD pfet_03v3 w=4.0u l=0.28u
XP31_0 d1_x1 D1 VDD VDD pfet_03v3 w=2.0u l=0.28u
XP32_0 d1_a T0 d1_x1 VDD pfet_03v3 w=2.0u l=0.28u
XN33_0 d1_a D1 VSS VSS nfet_03v3 w=1.0u l=0.28u
XP34_0 d1_b T0 VDD VDD pfet_03v3 w=2.0u l=0.28u
XN35_0 d1_b d1_a d1_x2 VSS nfet_03v3 w=2.0u l=0.28u
XN36_0 d1_x2 T0 VSS VSS nfet_03v3 w=2.0u l=0.28u
XP37_0 D1 d1_b VDD VDD pfet_03v3 w=3.0u l=0.28u
XN38_0 D1 T0 d1_x3 VSS nfet_03v3 w=2.0u l=0.28u
XN39_0 d1_x3 d1_b VSS VSS nfet_03v3 w=2.0u l=0.28u
XN40_0 D1 ENB VSS VSS nfet_03v3 w=1.0u l=0.28u
XP41_0 d2_x1 D2 VDD VDD pfet_03v3 w=2.0u l=0.28u
XP42_0 d2_a D1 d2_x1 VDD pfet_03v3 w=2.0u l=0.28u
XN43_0 d2_a D2 VSS VSS nfet_03v3 w=1.0u l=0.28u
XP44_0 d2_b D1 VDD VDD pfet_03v3 w=2.0u l=0.28u
XN45_0 d2_b d2_a d2_x2 VSS nfet_03v3 w=2.0u l=0.28u
XN46_0 d2_x2 D1 VSS VSS nfet_03v3 w=2.0u l=0.28u
XP47_0 D2 d2_b VDD VDD pfet_03v3 w=3.0u l=0.28u
XN48_0 D2 D1 d2_x3 VSS nfet_03v3 w=2.0u l=0.28u
XN49_0 d2_x3 d2_b VSS VSS nfet_03v3 w=2.0u l=0.28u
XN50_0 D2 ENB VSS VSS nfet_03v3 w=1.0u l=0.28u
XN51_0 OB D2 VSS VSS nfet_03v3 w=2.0u l=0.28u
XP52_0 OB D2 VDD VDD pfet_03v3 w=4.0u l=0.28u
XN53_0 OUT OB VSS VSS nfet_03v3 w=4.0u l=0.28u
XP54_0 OUT OB VDD VDD pfet_03v3 w=8.0u l=0.28u
.ends
