* pt_adc_i: transistor-level schematic of converter block adc_i (gf180mcuD).
* Generated by analog/converters/flow.py from circuits.py; do not edit.
* Standard cells: include /pdk/gf180mcuD/libs.ref/gf180mcu_fd_sc_mcu7t5v0/spice/gf180mcu_fd_sc_mcu7t5v0.spice
* v2: custom 3.3 V asynchronous SAR loop (circuits.sar_core); adc_code_reg macro = output register
.subckt adc_code_reg done done_o en overload VDD VSS bp[0] bp[1] bp[2] bp[3] bp[4] bp[5] bp[6] bp[7] bp[8] bp[9] code_tc[0] code_tc[1] code_tc[2] code_tc[3] code_tc[4] code_tc[5] code_tc[6] code_tc[7] code_tc[8] code_tc[9]
XFILLER_0_104 VDD VDD VSS VSS gf180mcu_fd_sc_mcu7t5v0__fillcap_32
XFILLER_0_138 VDD VDD VSS VSS gf180mcu_fd_sc_mcu7t5v0__fillcap_32
XFILLER_0_172 VDD VDD VSS VSS gf180mcu_fd_sc_mcu7t5v0__fillcap_16
XFILLER_0_2 VDD VDD VSS VSS gf180mcu_fd_sc_mcu7t5v0__fillcap_32
XFILLER_0_36 VDD VDD VSS VSS gf180mcu_fd_sc_mcu7t5v0__fillcap_32
XFILLER_0_70 VDD VDD VSS VSS gf180mcu_fd_sc_mcu7t5v0__fillcap_32
XFILLER_10_104 VDD VDD VSS VSS gf180mcu_fd_sc_mcu7t5v0__fillcap_32
XFILLER_10_138 VDD VDD VSS VSS gf180mcu_fd_sc_mcu7t5v0__fillcap_32
XFILLER_10_172 VDD VDD VSS VSS gf180mcu_fd_sc_mcu7t5v0__fillcap_16
XFILLER_10_2 VDD VDD VSS VSS gf180mcu_fd_sc_mcu7t5v0__fillcap_32
XFILLER_10_36 VDD VDD VSS VSS gf180mcu_fd_sc_mcu7t5v0__fillcap_32
XFILLER_10_70 VDD VDD VSS VSS gf180mcu_fd_sc_mcu7t5v0__fillcap_32
XFILLER_1_120 VDD VDD VSS VSS gf180mcu_fd_sc_mcu7t5v0__fillcap_16
XFILLER_1_136 VDD VDD VSS VSS gf180mcu_fd_sc_mcu7t5v0__fillcap_4
XFILLER_1_142 VDD VDD VSS VSS gf180mcu_fd_sc_mcu7t5v0__fillcap_32
XFILLER_1_174 VDD VDD VSS VSS gf180mcu_fd_sc_mcu7t5v0__fillcap_8
XFILLER_1_18 VDD VDD VSS VSS gf180mcu_fd_sc_mcu7t5v0__fillcap_4
XFILLER_1_182 VDD VDD VSS VSS gf180mcu_fd_sc_mcu7t5v0__fillcap_4
XFILLER_1_186 VDD VDD VSS VSS gf180mcu_fd_sc_mcu7t5v0__fill_2
XFILLER_1_2 VDD VDD VSS VSS gf180mcu_fd_sc_mcu7t5v0__fillcap_16
XFILLER_1_22 VDD VDD VSS VSS gf180mcu_fd_sc_mcu7t5v0__fill_2
XFILLER_1_69 VDD VDD VSS VSS gf180mcu_fd_sc_mcu7t5v0__fill_1
XFILLER_1_72 VDD VDD VSS VSS gf180mcu_fd_sc_mcu7t5v0__fillcap_4
XFILLER_1_76 VDD VDD VSS VSS gf180mcu_fd_sc_mcu7t5v0__fill_2
XFILLER_1_88 VDD VDD VSS VSS gf180mcu_fd_sc_mcu7t5v0__fillcap_32
XFILLER_2_103 VDD VDD VSS VSS gf180mcu_fd_sc_mcu7t5v0__fill_2
XFILLER_2_107 VDD VDD VSS VSS gf180mcu_fd_sc_mcu7t5v0__fillcap_64
XFILLER_2_171 VDD VDD VSS VSS gf180mcu_fd_sc_mcu7t5v0__fillcap_4
XFILLER_2_177 VDD VDD VSS VSS gf180mcu_fd_sc_mcu7t5v0__fillcap_8
XFILLER_2_185 VDD VDD VSS VSS gf180mcu_fd_sc_mcu7t5v0__fill_2
XFILLER_2_187 VDD VDD VSS VSS gf180mcu_fd_sc_mcu7t5v0__fill_1
XFILLER_2_2 VDD VDD VSS VSS gf180mcu_fd_sc_mcu7t5v0__fillcap_32
XFILLER_2_34 VDD VDD VSS VSS gf180mcu_fd_sc_mcu7t5v0__fill_1
XFILLER_2_37 VDD VDD VSS VSS gf180mcu_fd_sc_mcu7t5v0__fillcap_16
XFILLER_2_53 VDD VDD VSS VSS gf180mcu_fd_sc_mcu7t5v0__fillcap_8
XFILLER_2_87 VDD VDD VSS VSS gf180mcu_fd_sc_mcu7t5v0__fillcap_16
XFILLER_3_128 VDD VDD VSS VSS gf180mcu_fd_sc_mcu7t5v0__fillcap_8
XFILLER_3_136 VDD VDD VSS VSS gf180mcu_fd_sc_mcu7t5v0__fillcap_4
XFILLER_3_142 VDD VDD VSS VSS gf180mcu_fd_sc_mcu7t5v0__fillcap_32
XFILLER_3_174 VDD VDD VSS VSS gf180mcu_fd_sc_mcu7t5v0__fillcap_8
XFILLER_3_18 VDD VDD VSS VSS gf180mcu_fd_sc_mcu7t5v0__fillcap_4
XFILLER_3_182 VDD VDD VSS VSS gf180mcu_fd_sc_mcu7t5v0__fillcap_4
XFILLER_3_186 VDD VDD VSS VSS gf180mcu_fd_sc_mcu7t5v0__fill_2
XFILLER_3_2 VDD VDD VSS VSS gf180mcu_fd_sc_mcu7t5v0__fillcap_16
XFILLER_3_22 VDD VDD VSS VSS gf180mcu_fd_sc_mcu7t5v0__fill_2
XFILLER_3_58 VDD VDD VSS VSS gf180mcu_fd_sc_mcu7t5v0__fill_2
XFILLER_3_60 VDD VDD VSS VSS gf180mcu_fd_sc_mcu7t5v0__fill_1
XFILLER_3_72 VDD VDD VSS VSS gf180mcu_fd_sc_mcu7t5v0__fill_1
XFILLER_3_84 VDD VDD VSS VSS gf180mcu_fd_sc_mcu7t5v0__fillcap_8
XFILLER_3_92 VDD VDD VSS VSS gf180mcu_fd_sc_mcu7t5v0__fill_2
XFILLER_4_101 VDD VDD VSS VSS gf180mcu_fd_sc_mcu7t5v0__fillcap_4
XFILLER_4_107 VDD VDD VSS VSS gf180mcu_fd_sc_mcu7t5v0__fillcap_16
XFILLER_4_123 VDD VDD VSS VSS gf180mcu_fd_sc_mcu7t5v0__fill_1
XFILLER_4_158 VDD VDD VSS VSS gf180mcu_fd_sc_mcu7t5v0__fillcap_16
XFILLER_4_174 VDD VDD VSS VSS gf180mcu_fd_sc_mcu7t5v0__fill_1
XFILLER_4_177 VDD VDD VSS VSS gf180mcu_fd_sc_mcu7t5v0__fillcap_8
XFILLER_4_185 VDD VDD VSS VSS gf180mcu_fd_sc_mcu7t5v0__fill_2
XFILLER_4_187 VDD VDD VSS VSS gf180mcu_fd_sc_mcu7t5v0__fill_1
XFILLER_4_2 VDD VDD VSS VSS gf180mcu_fd_sc_mcu7t5v0__fillcap_32
XFILLER_4_34 VDD VDD VSS VSS gf180mcu_fd_sc_mcu7t5v0__fill_1
XFILLER_4_37 VDD VDD VSS VSS gf180mcu_fd_sc_mcu7t5v0__fillcap_16
XFILLER_4_53 VDD VDD VSS VSS gf180mcu_fd_sc_mcu7t5v0__fillcap_4
XFILLER_4_57 VDD VDD VSS VSS gf180mcu_fd_sc_mcu7t5v0__fill_2
XFILLER_4_93 VDD VDD VSS VSS gf180mcu_fd_sc_mcu7t5v0__fillcap_8
XFILLER_5_101 VDD VDD VSS VSS gf180mcu_fd_sc_mcu7t5v0__fillcap_32
XFILLER_5_133 VDD VDD VSS VSS gf180mcu_fd_sc_mcu7t5v0__fillcap_4
XFILLER_5_137 VDD VDD VSS VSS gf180mcu_fd_sc_mcu7t5v0__fill_2
XFILLER_5_139 VDD VDD VSS VSS gf180mcu_fd_sc_mcu7t5v0__fill_1
XFILLER_5_142 VDD VDD VSS VSS gf180mcu_fd_sc_mcu7t5v0__fillcap_32
XFILLER_5_174 VDD VDD VSS VSS gf180mcu_fd_sc_mcu7t5v0__fillcap_8
XFILLER_5_182 VDD VDD VSS VSS gf180mcu_fd_sc_mcu7t5v0__fillcap_4
XFILLER_5_186 VDD VDD VSS VSS gf180mcu_fd_sc_mcu7t5v0__fill_2
XFILLER_5_2 VDD VDD VSS VSS gf180mcu_fd_sc_mcu7t5v0__fillcap_64
XFILLER_5_66 VDD VDD VSS VSS gf180mcu_fd_sc_mcu7t5v0__fillcap_4
XFILLER_5_72 VDD VDD VSS VSS gf180mcu_fd_sc_mcu7t5v0__fillcap_16
XFILLER_5_88 VDD VDD VSS VSS gf180mcu_fd_sc_mcu7t5v0__fillcap_8
XFILLER_5_96 VDD VDD VSS VSS gf180mcu_fd_sc_mcu7t5v0__fill_1
XFILLER_6_102 VDD VDD VSS VSS gf180mcu_fd_sc_mcu7t5v0__fill_2
XFILLER_6_104 VDD VDD VSS VSS gf180mcu_fd_sc_mcu7t5v0__fill_1
XFILLER_6_107 VDD VDD VSS VSS gf180mcu_fd_sc_mcu7t5v0__fillcap_64
XFILLER_6_171 VDD VDD VSS VSS gf180mcu_fd_sc_mcu7t5v0__fillcap_4
XFILLER_6_177 VDD VDD VSS VSS gf180mcu_fd_sc_mcu7t5v0__fillcap_8
XFILLER_6_185 VDD VDD VSS VSS gf180mcu_fd_sc_mcu7t5v0__fill_2
XFILLER_6_187 VDD VDD VSS VSS gf180mcu_fd_sc_mcu7t5v0__fill_1
XFILLER_6_2 VDD VDD VSS VSS gf180mcu_fd_sc_mcu7t5v0__fillcap_32
XFILLER_6_34 VDD VDD VSS VSS gf180mcu_fd_sc_mcu7t5v0__fill_1
XFILLER_6_37 VDD VDD VSS VSS gf180mcu_fd_sc_mcu7t5v0__fillcap_8
XFILLER_6_45 VDD VDD VSS VSS gf180mcu_fd_sc_mcu7t5v0__fill_2
XFILLER_6_47 VDD VDD VSS VSS gf180mcu_fd_sc_mcu7t5v0__fill_1
XFILLER_6_82 VDD VDD VSS VSS gf180mcu_fd_sc_mcu7t5v0__fillcap_16
XFILLER_6_98 VDD VDD VSS VSS gf180mcu_fd_sc_mcu7t5v0__fillcap_4
XFILLER_7_104 VDD VDD VSS VSS gf180mcu_fd_sc_mcu7t5v0__fill_2
XFILLER_7_142 VDD VDD VSS VSS gf180mcu_fd_sc_mcu7t5v0__fillcap_32
XFILLER_7_174 VDD VDD VSS VSS gf180mcu_fd_sc_mcu7t5v0__fillcap_8
XFILLER_7_18 VDD VDD VSS VSS gf180mcu_fd_sc_mcu7t5v0__fillcap_8
XFILLER_7_182 VDD VDD VSS VSS gf180mcu_fd_sc_mcu7t5v0__fillcap_4
XFILLER_7_186 VDD VDD VSS VSS gf180mcu_fd_sc_mcu7t5v0__fill_2
XFILLER_7_2 VDD VDD VSS VSS gf180mcu_fd_sc_mcu7t5v0__fillcap_16
XFILLER_7_26 VDD VDD VSS VSS gf180mcu_fd_sc_mcu7t5v0__fillcap_4
XFILLER_7_30 VDD VDD VSS VSS gf180mcu_fd_sc_mcu7t5v0__fill_1
XFILLER_7_65 VDD VDD VSS VSS gf180mcu_fd_sc_mcu7t5v0__fillcap_4
XFILLER_7_69 VDD VDD VSS VSS gf180mcu_fd_sc_mcu7t5v0__fill_1
XFILLER_7_72 VDD VDD VSS VSS gf180mcu_fd_sc_mcu7t5v0__fillcap_32
XFILLER_8_103 VDD VDD VSS VSS gf180mcu_fd_sc_mcu7t5v0__fill_2
XFILLER_8_107 VDD VDD VSS VSS gf180mcu_fd_sc_mcu7t5v0__fillcap_32
XFILLER_8_139 VDD VDD VSS VSS gf180mcu_fd_sc_mcu7t5v0__fillcap_16
XFILLER_8_155 VDD VDD VSS VSS gf180mcu_fd_sc_mcu7t5v0__fillcap_8
XFILLER_8_163 VDD VDD VSS VSS gf180mcu_fd_sc_mcu7t5v0__fillcap_4
XFILLER_8_177 VDD VDD VSS VSS gf180mcu_fd_sc_mcu7t5v0__fillcap_8
XFILLER_8_185 VDD VDD VSS VSS gf180mcu_fd_sc_mcu7t5v0__fill_2
XFILLER_8_187 VDD VDD VSS VSS gf180mcu_fd_sc_mcu7t5v0__fill_1
XFILLER_8_2 VDD VDD VSS VSS gf180mcu_fd_sc_mcu7t5v0__fillcap_32
XFILLER_8_34 VDD VDD VSS VSS gf180mcu_fd_sc_mcu7t5v0__fill_1
XFILLER_8_37 VDD VDD VSS VSS gf180mcu_fd_sc_mcu7t5v0__fillcap_32
XFILLER_9_114 VDD VDD VSS VSS gf180mcu_fd_sc_mcu7t5v0__fillcap_16
XFILLER_9_130 VDD VDD VSS VSS gf180mcu_fd_sc_mcu7t5v0__fillcap_8
XFILLER_9_138 VDD VDD VSS VSS gf180mcu_fd_sc_mcu7t5v0__fill_2
XFILLER_9_142 VDD VDD VSS VSS gf180mcu_fd_sc_mcu7t5v0__fillcap_32
XFILLER_9_174 VDD VDD VSS VSS gf180mcu_fd_sc_mcu7t5v0__fillcap_8
XFILLER_9_18 VDD VDD VSS VSS gf180mcu_fd_sc_mcu7t5v0__fillcap_8
XFILLER_9_182 VDD VDD VSS VSS gf180mcu_fd_sc_mcu7t5v0__fillcap_4
XFILLER_9_186 VDD VDD VSS VSS gf180mcu_fd_sc_mcu7t5v0__fill_2
XFILLER_9_2 VDD VDD VSS VSS gf180mcu_fd_sc_mcu7t5v0__fillcap_16
XFILLER_9_26 VDD VDD VSS VSS gf180mcu_fd_sc_mcu7t5v0__fill_1
XFILLER_9_61 VDD VDD VSS VSS gf180mcu_fd_sc_mcu7t5v0__fillcap_8
XFILLER_9_69 VDD VDD VSS VSS gf180mcu_fd_sc_mcu7t5v0__fill_1
XFILLER_9_72 VDD VDD VSS VSS gf180mcu_fd_sc_mcu7t5v0__fillcap_8
XPHY_EDGE_ROW_0_Left_11 VDD VDD VSS VSS gf180mcu_fd_sc_mcu7t5v0__endcap
XPHY_EDGE_ROW_0_Right_0 VDD VDD VSS VSS gf180mcu_fd_sc_mcu7t5v0__endcap
XPHY_EDGE_ROW_10_Left_21 VDD VDD VSS VSS gf180mcu_fd_sc_mcu7t5v0__endcap
XPHY_EDGE_ROW_10_Right_10 VDD VDD VSS VSS gf180mcu_fd_sc_mcu7t5v0__endcap
XPHY_EDGE_ROW_1_Left_12 VDD VDD VSS VSS gf180mcu_fd_sc_mcu7t5v0__endcap
XPHY_EDGE_ROW_1_Right_1 VDD VDD VSS VSS gf180mcu_fd_sc_mcu7t5v0__endcap
XPHY_EDGE_ROW_2_Left_13 VDD VDD VSS VSS gf180mcu_fd_sc_mcu7t5v0__endcap
XPHY_EDGE_ROW_2_Right_2 VDD VDD VSS VSS gf180mcu_fd_sc_mcu7t5v0__endcap
XPHY_EDGE_ROW_3_Left_14 VDD VDD VSS VSS gf180mcu_fd_sc_mcu7t5v0__endcap
XPHY_EDGE_ROW_3_Right_3 VDD VDD VSS VSS gf180mcu_fd_sc_mcu7t5v0__endcap
XPHY_EDGE_ROW_4_Left_15 VDD VDD VSS VSS gf180mcu_fd_sc_mcu7t5v0__endcap
XPHY_EDGE_ROW_4_Right_4 VDD VDD VSS VSS gf180mcu_fd_sc_mcu7t5v0__endcap
XPHY_EDGE_ROW_5_Left_16 VDD VDD VSS VSS gf180mcu_fd_sc_mcu7t5v0__endcap
XPHY_EDGE_ROW_5_Right_5 VDD VDD VSS VSS gf180mcu_fd_sc_mcu7t5v0__endcap
XPHY_EDGE_ROW_6_Left_17 VDD VDD VSS VSS gf180mcu_fd_sc_mcu7t5v0__endcap
XPHY_EDGE_ROW_6_Right_6 VDD VDD VSS VSS gf180mcu_fd_sc_mcu7t5v0__endcap
XPHY_EDGE_ROW_7_Left_18 VDD VDD VSS VSS gf180mcu_fd_sc_mcu7t5v0__endcap
XPHY_EDGE_ROW_7_Right_7 VDD VDD VSS VSS gf180mcu_fd_sc_mcu7t5v0__endcap
XPHY_EDGE_ROW_8_Left_19 VDD VDD VSS VSS gf180mcu_fd_sc_mcu7t5v0__endcap
XPHY_EDGE_ROW_8_Right_8 VDD VDD VSS VSS gf180mcu_fd_sc_mcu7t5v0__endcap
XPHY_EDGE_ROW_9_Left_20 VDD VDD VSS VSS gf180mcu_fd_sc_mcu7t5v0__endcap
XPHY_EDGE_ROW_9_Right_9 VDD VDD VSS VSS gf180mcu_fd_sc_mcu7t5v0__endcap
XTAP_TAPCELL_ROW_0_22 VDD VSS gf180mcu_fd_sc_mcu7t5v0__filltie
XTAP_TAPCELL_ROW_0_23 VDD VSS gf180mcu_fd_sc_mcu7t5v0__filltie
XTAP_TAPCELL_ROW_0_24 VDD VSS gf180mcu_fd_sc_mcu7t5v0__filltie
XTAP_TAPCELL_ROW_0_25 VDD VSS gf180mcu_fd_sc_mcu7t5v0__filltie
XTAP_TAPCELL_ROW_0_26 VDD VSS gf180mcu_fd_sc_mcu7t5v0__filltie
XTAP_TAPCELL_ROW_10_49 VDD VSS gf180mcu_fd_sc_mcu7t5v0__filltie
XTAP_TAPCELL_ROW_10_50 VDD VSS gf180mcu_fd_sc_mcu7t5v0__filltie
XTAP_TAPCELL_ROW_10_51 VDD VSS gf180mcu_fd_sc_mcu7t5v0__filltie
XTAP_TAPCELL_ROW_10_52 VDD VSS gf180mcu_fd_sc_mcu7t5v0__filltie
XTAP_TAPCELL_ROW_10_53 VDD VSS gf180mcu_fd_sc_mcu7t5v0__filltie
XTAP_TAPCELL_ROW_1_27 VDD VSS gf180mcu_fd_sc_mcu7t5v0__filltie
XTAP_TAPCELL_ROW_1_28 VDD VSS gf180mcu_fd_sc_mcu7t5v0__filltie
XTAP_TAPCELL_ROW_2_29 VDD VSS gf180mcu_fd_sc_mcu7t5v0__filltie
XTAP_TAPCELL_ROW_2_30 VDD VSS gf180mcu_fd_sc_mcu7t5v0__filltie
XTAP_TAPCELL_ROW_2_31 VDD VSS gf180mcu_fd_sc_mcu7t5v0__filltie
XTAP_TAPCELL_ROW_3_32 VDD VSS gf180mcu_fd_sc_mcu7t5v0__filltie
XTAP_TAPCELL_ROW_3_33 VDD VSS gf180mcu_fd_sc_mcu7t5v0__filltie
XTAP_TAPCELL_ROW_4_34 VDD VSS gf180mcu_fd_sc_mcu7t5v0__filltie
XTAP_TAPCELL_ROW_4_35 VDD VSS gf180mcu_fd_sc_mcu7t5v0__filltie
XTAP_TAPCELL_ROW_4_36 VDD VSS gf180mcu_fd_sc_mcu7t5v0__filltie
XTAP_TAPCELL_ROW_5_37 VDD VSS gf180mcu_fd_sc_mcu7t5v0__filltie
XTAP_TAPCELL_ROW_5_38 VDD VSS gf180mcu_fd_sc_mcu7t5v0__filltie
XTAP_TAPCELL_ROW_6_39 VDD VSS gf180mcu_fd_sc_mcu7t5v0__filltie
XTAP_TAPCELL_ROW_6_40 VDD VSS gf180mcu_fd_sc_mcu7t5v0__filltie
XTAP_TAPCELL_ROW_6_41 VDD VSS gf180mcu_fd_sc_mcu7t5v0__filltie
XTAP_TAPCELL_ROW_7_42 VDD VSS gf180mcu_fd_sc_mcu7t5v0__filltie
XTAP_TAPCELL_ROW_7_43 VDD VSS gf180mcu_fd_sc_mcu7t5v0__filltie
XTAP_TAPCELL_ROW_8_44 VDD VSS gf180mcu_fd_sc_mcu7t5v0__filltie
XTAP_TAPCELL_ROW_8_45 VDD VSS gf180mcu_fd_sc_mcu7t5v0__filltie
XTAP_TAPCELL_ROW_8_46 VDD VSS gf180mcu_fd_sc_mcu7t5v0__filltie
XTAP_TAPCELL_ROW_9_47 VDD VSS gf180mcu_fd_sc_mcu7t5v0__filltie
XTAP_TAPCELL_ROW_9_48 VDD VSS gf180mcu_fd_sc_mcu7t5v0__filltie
X_08_ bp[0] _00_ VDD VDD VSS VSS gf180mcu_fd_sc_mcu7t5v0__clkinv_1
X_09_ bp[9] bp[8] bp[1] bp[0] _02_ VDD VDD VSS VSS gf180mcu_fd_sc_mcu7t5v0__and4_1
X_10_ bp[5] bp[4] bp[7] bp[6] _03_ VDD VDD VSS VSS gf180mcu_fd_sc_mcu7t5v0__and4_1
X_11_ bp[3] bp[2] _02_ _03_ _04_ VDD VDD VSS VSS gf180mcu_fd_sc_mcu7t5v0__nand4_1
X_12_ bp[9] bp[8] bp[1] bp[0] _05_ VDD VDD VSS VSS gf180mcu_fd_sc_mcu7t5v0__nor4_1
X_13_ bp[5] bp[4] bp[7] bp[6] _06_ VDD VDD VSS VSS gf180mcu_fd_sc_mcu7t5v0__nor4_1
X_14_ _05_ _06_ _07_ VDD VDD VSS VSS gf180mcu_fd_sc_mcu7t5v0__nand2_1
X_15_ bp[3] bp[2] _07_ _04_ _01_ VDD VDD VSS VSS gf180mcu_fd_sc_mcu7t5v0__oai31_1
X_16_ en done done_o VDD VDD VSS VSS gf180mcu_fd_sc_mcu7t5v0__and2_1
X_17_ bp[9] en done code_tc[0] VDD VDD VSS VSS gf180mcu_fd_sc_mcu7t5v0__dffrnq_1
X_18_ bp[8] en done code_tc[1] VDD VDD VSS VSS gf180mcu_fd_sc_mcu7t5v0__dffrnq_1
X_19_ bp[7] en done code_tc[2] VDD VDD VSS VSS gf180mcu_fd_sc_mcu7t5v0__dffrnq_1
X_20_ bp[6] en done code_tc[3] VDD VDD VSS VSS gf180mcu_fd_sc_mcu7t5v0__dffrnq_1
X_21_ bp[5] en done code_tc[4] VDD VDD VSS VSS gf180mcu_fd_sc_mcu7t5v0__dffrnq_1
X_22_ bp[4] en done code_tc[5] VDD VDD VSS VSS gf180mcu_fd_sc_mcu7t5v0__dffrnq_1
X_23_ bp[3] en done code_tc[6] VDD VDD VSS VSS gf180mcu_fd_sc_mcu7t5v0__dffrnq_1
X_24_ bp[2] en done code_tc[7] VDD VDD VSS VSS gf180mcu_fd_sc_mcu7t5v0__dffrnq_1
X_25_ bp[1] en done code_tc[8] VDD VDD VSS VSS gf180mcu_fd_sc_mcu7t5v0__dffrnq_1
X_26_ _00_ en done code_tc[9] VDD VDD VSS VSS gf180mcu_fd_sc_mcu7t5v0__dffrnq_1
X_27_ _01_ en done overload VDD VDD VSS VSS gf180mcu_fd_sc_mcu7t5v0__dffrnq_1
.ends

.subckt pt_adc_i VDD VSS INP INN VCM VREF IBIAS CLKP CLKN EN TEST0 TEST1 CODE0 CODE1 CODE2 CODE3 CODE4 CODE5 CODE6 CODE7 CODE8 CODE9 DONE OVERLOAD ATB_BIAS
XIEN_0 ENB EN VSS VSS nfet_03v3 w=1.0u l=0.28u
XIEP_0 ENB EN VDD VDD pfet_03v3 w=2.0u l=0.28u
XBSW_0 IBIAS EN ATB_BIAS VSS nfet_03v3 w=4u l=0.5u
XBD_0 ATB_BIAS ATB_BIAS VSS VSS nfet_03v3 w=4u l=2u
XBPD_0 ATB_BIAS ENB VSS VSS nfet_03v3 w=1u l=0.5u
XKMT_0 Kt ATB_BIAS VSS VSS nfet_03v3 w=16u l=2u
XKM1_0 Ka CLKP Kt VSS nfet_03v3 w=4u l=0.5u
XKM2_0 Kx CLKN Kt VSS nfet_03v3 w=4u l=0.5u
XKM3_0 Ka Ka VDD VDD pfet_03v3 w=4u l=0.5u
XKM4_0 Kx Ka VDD VDD pfet_03v3 w=4u l=0.5u
XKMU_0 Kx EN VDD VDD pfet_03v3 w=1u l=0.28u
XKI1N_0 Ky1 Kx VSS VSS nfet_03v3 w=1.0u l=0.28u
XKI1P_0 Ky1 Kx VDD VDD pfet_03v3 w=2.0u l=0.28u
XKI2N_0 Ky2 Ky1 VSS VSS nfet_03v3 w=1.0u l=0.28u
XKI2P_0 Ky2 Ky1 VDD VDD pfet_03v3 w=2.0u l=0.28u
XKGNA_0 Kz Ky2 KG_m VSS nfet_03v3 w=2.0u l=0.28u
XKGNB_0 KG_m EN VSS VSS nfet_03v3 w=2.0u l=0.28u
XKGPA_0 Kz Ky2 VDD VDD pfet_03v3 w=2.0u l=0.28u
XKGPB_0 Kz EN VDD VDD pfet_03v3 w=2.0u l=0.28u
XKI3N_0 SAMPLE Kz VSS VSS nfet_03v3 w=2u l=0.28u
XKI3P_0 SAMPLE Kz VDD VDD pfet_03v3 w=4u l=0.28u
XGTZNA_0 TZ TEST0 VSS VSS nfet_03v3 w=1.0u l=0.28u
XGTZNB_0 TZ TEST1 VSS VSS nfet_03v3 w=1.0u l=0.28u
XGTZPA_0 GTZ_m TEST0 VDD VDD pfet_03v3 w=4.0u l=0.28u
XGTZPB_0 TZ TEST1 GTZ_m VDD pfet_03v3 w=4.0u l=0.28u
XGTZBN_0 TZB TZ VSS VSS nfet_03v3 w=1.0u l=0.28u
XGTZBP_0 TZB TZ VDD VDD pfet_03v3 w=2.0u l=0.28u
XGSENA_0 SEB SAMPLE GSE_m VSS nfet_03v3 w=2.0u l=0.28u
XGSENB_0 GSE_m EN VSS VSS nfet_03v3 w=2.0u l=0.28u
XGSEPA_0 SEB SAMPLE VDD VDD pfet_03v3 w=2.0u l=0.28u
XGSEPB_0 SEB EN VDD VDD pfet_03v3 w=2.0u l=0.28u
XGSEIN_0 SEN SEB VSS VSS nfet_03v3 w=2u l=0.28u
XGSEIP_0 SEN SEB VDD VDD pfet_03v3 w=4u l=0.28u
XGBTNA_0 BOOTBL SEN GBT_m VSS nfet_03v3 w=4u l=0.28u
XGBTNB_0 GBT_m TZ VSS VSS nfet_03v3 w=4u l=0.28u
XGBTPA_0 BOOTBL SEN VDD VDD pfet_03v3 w=4u l=0.28u
XGBTPB_0 BOOTBL TZ VDD VDD pfet_03v3 w=4u l=0.28u
XGBTIN_0 BOOTL BOOTBL VSS VSS nfet_03v3 w=4u l=0.28u
XGBTIP_0 BOOTL BOOTBL VDD VDD pfet_03v3 w=8u l=0.28u
XGVTNA_0 VCMTB SEN GVT_m VSS nfet_03v3 w=2.0u l=0.28u
XGVTNB_0 GVT_m TZB VSS VSS nfet_03v3 w=2.0u l=0.28u
XGVTPA_0 VCMTB SEN VDD VDD pfet_03v3 w=2.0u l=0.28u
XGVTPB_0 VCMTB TZB VDD VDD pfet_03v3 w=2.0u l=0.28u
XGVTIN_0 VCMTL VCMTB VSS VSS nfet_03v3 w=2u l=0.28u
XGVTIP_0 VCMTL VCMTB VDD VDD pfet_03v3 w=4u l=0.28u
XGLRAN_0 LSBRB SEN VSS VSS nfet_03v3 w=1.0u l=0.28u
XGLRAP_0 LSBRB SEN VDD VDD pfet_03v3 w=2.0u l=0.28u
XGLRBN_0 LSBRL LSBRB VSS VSS nfet_03v3 w=2u l=0.28u
XGLRBP_0 LSBRL LSBRB VDD VDD pfet_03v3 w=4u l=0.28u
XSPMS_0 INP SPg TOPP VSS nfet_03v3 w=8u l=0.28u
XSPCB_0 SPtb SPbb cap_mim_2f0_m4m5_noshield c_width=10u c_length=10u
XSPM1_0 SPbb BOOTBL VSS VSS nfet_03v3 w=2u l=0.28u
XSPM2_0 SPtb SPg VDD SPtb pfet_03v3 w=2u l=0.28u
XSPM3_0 SPg SPh SPtb SPtb pfet_03v3 w=4u l=0.28u
XSPM4_0 SPh BOOTL SPbb VSS nfet_03v3 w=1u l=0.28u
XSPM5_0 SPh BOOTL VDD VDD pfet_03v3 w=1u l=0.28u
XSPM6_0 SPbb SPg INP VSS nfet_03v3 w=4u l=0.28u
XSPM7_0 SPg VDD SPgx VSS nfet_03v3 w=2u l=0.28u
XSPM8_0 SPgx BOOTBL VSS VSS nfet_03v3 w=2u l=0.28u
XVTP_0 TOPP VCMTL VCM VSS nfet_03v3 w=2u l=0.28u
XLRP_0 LSBP LSBRL VCM VSS nfet_03v3 w=1u l=0.28u
XSNMS_0 INN SNg TOPN VSS nfet_03v3 w=8u l=0.28u
XSNCB_0 SNtb SNbb cap_mim_2f0_m4m5_noshield c_width=10u c_length=10u
XSNM1_0 SNbb BOOTBL VSS VSS nfet_03v3 w=2u l=0.28u
XSNM2_0 SNtb SNg VDD SNtb pfet_03v3 w=2u l=0.28u
XSNM3_0 SNg SNh SNtb SNtb pfet_03v3 w=4u l=0.28u
XSNM4_0 SNh BOOTL SNbb VSS nfet_03v3 w=1u l=0.28u
XSNM5_0 SNh BOOTL VDD VDD pfet_03v3 w=1u l=0.28u
XSNM6_0 SNbb SNg INN VSS nfet_03v3 w=4u l=0.28u
XSNM7_0 SNg VDD SNgx VSS nfet_03v3 w=2u l=0.28u
XSNM8_0 SNgx BOOTBL VSS VSS nfet_03v3 w=2u l=0.28u
XVTN_0 TOPN VCMTL VCM VSS nfet_03v3 w=2u l=0.28u
XLRN_0 LSBN LSBRL VCM VSS nfet_03v3 w=1u l=0.28u
XQB1N_0 Qckb CMPCLK VSS VSS nfet_03v3 w=2u l=0.28u
XQB1P_0 Qckb CMPCLK VDD VDD pfet_03v3 w=4u l=0.28u
XQB2N_0 Qck Qckb VSS VSS nfet_03v3 w=8u l=0.28u
XQB2P_0 Qck Qckb VDD VDD pfet_03v3 w=16u l=0.28u
XQMT_0 Qct Qck VSS VSS nfet_03v3 w=8u l=0.28u
XQMIP_0 Qcn1 TOPP Qct VSS nfet_03v3 w=8u l=0.28u
XQMIN_0 Qcn2 TOPN Qct VSS nfet_03v3 w=8u l=0.28u
XQMNP_0 Qqn Qqp Qcn1 VSS nfet_03v3 w=4u l=0.28u
XQMNN_0 Qqp Qqn Qcn2 VSS nfet_03v3 w=4u l=0.28u
XQMPP_0 Qqn Qqp VDD VDD pfet_03v3 w=4u l=0.28u
XQMPN_0 Qqp Qqn VDD VDD pfet_03v3 w=4u l=0.28u
XQMR1_0 Qcn1 Qck VDD VDD pfet_03v3 w=2u l=0.28u
XQMR2_0 Qcn2 Qck VDD VDD pfet_03v3 w=2u l=0.28u
XQMRP_0 Qqp Qck VDD VDD pfet_03v3 w=2u l=0.28u
XQMRN_0 Qqn Qck VDD VDD pfet_03v3 w=2u l=0.28u
XQIPN_0 DP Qqn VSS VSS nfet_03v3 w=6u l=0.28u
XQIPP_0 DP Qqn VDD VDD pfet_03v3 w=12u l=0.28u
XQINN_0 DN Qqp VSS VSS nfet_03v3 w=6u l=0.28u
XQINP_0 DN Qqp VDD VDD pfet_03v3 w=12u l=0.28u
XMGP0_0 BOTP0 GP0 VSS VSS nfet_03v3 w=1u l=0.28u
XMRP0_0 BOTP0 RP0 VREF VSS nfet_03v3 w=1u l=0.28u
XMGP1_0 BOTP1 GP1 VSS VSS nfet_03v3 w=1u l=0.28u
XMRP1_0 BOTP1 RP1 VREF VSS nfet_03v3 w=1u l=0.28u
XMGP2_0 BOTP2 GP2 VSS VSS nfet_03v3 w=1.2u l=0.28u
XMRP2_0 BOTP2 RP2 VREF VSS nfet_03v3 w=1.2u l=0.28u
XMGP3_0 BOTP3 GP3 VSS VSS nfet_03v3 w=2.5u l=0.28u
XMRP3_0 BOTP3 RP3 VREF VSS nfet_03v3 w=2.5u l=0.28u
XMGP4_0 BOTP4 GP4 VSS VSS nfet_03v3 w=5u l=0.28u
XMRP4_0 BOTP4 RP4 VREF VSS nfet_03v3 w=5u l=0.28u
XMGP5_0 BOTP5 GP5 VSS VSS nfet_03v3 w=10u l=0.28u
XMRP5_0 BOTP5 RP5 VREF VSS nfet_03v3 w=10u l=0.28u
XMGP6_0 BOTP6 GP6 VSS VSS nfet_03v3 w=1u l=0.28u
XMRP6_0 BOTP6 RP6 VREF VSS nfet_03v3 w=1u l=0.28u
XMGP7_0 BOTP7 GP7 VSS VSS nfet_03v3 w=2u l=0.28u
XMRP7_0 BOTP7 RP7 VREF VSS nfet_03v3 w=2u l=0.28u
XMGP8_0 BOTP8 GP8 VSS VSS nfet_03v3 w=4u l=0.28u
XMRP8_0 BOTP8 RP8 VREF VSS nfet_03v3 w=4u l=0.28u
XMGN0_0 BOTN0 GN0 VSS VSS nfet_03v3 w=1u l=0.28u
XMRN0_0 BOTN0 RN0 VREF VSS nfet_03v3 w=1u l=0.28u
XMGN1_0 BOTN1 GN1 VSS VSS nfet_03v3 w=1u l=0.28u
XMRN1_0 BOTN1 RN1 VREF VSS nfet_03v3 w=1u l=0.28u
XMGN2_0 BOTN2 GN2 VSS VSS nfet_03v3 w=1.2u l=0.28u
XMRN2_0 BOTN2 RN2 VREF VSS nfet_03v3 w=1.2u l=0.28u
XMGN3_0 BOTN3 GN3 VSS VSS nfet_03v3 w=2.5u l=0.28u
XMRN3_0 BOTN3 RN3 VREF VSS nfet_03v3 w=2.5u l=0.28u
XMGN4_0 BOTN4 GN4 VSS VSS nfet_03v3 w=5u l=0.28u
XMRN4_0 BOTN4 RN4 VREF VSS nfet_03v3 w=5u l=0.28u
XMGN5_0 BOTN5 GN5 VSS VSS nfet_03v3 w=10u l=0.28u
XMRN5_0 BOTN5 RN5 VREF VSS nfet_03v3 w=10u l=0.28u
XMGN6_0 BOTN6 GN6 VSS VSS nfet_03v3 w=1u l=0.28u
XMRN6_0 BOTN6 RN6 VREF VSS nfet_03v3 w=1u l=0.28u
XMGN7_0 BOTN7 GN7 VSS VSS nfet_03v3 w=2u l=0.28u
XMRN7_0 BOTN7 RN7 VREF VSS nfet_03v3 w=2u l=0.28u
XMGN8_0 BOTN8 GN8 VSS VSS nfet_03v3 w=4u l=0.28u
XMRN8_0 BOTN8 RN8 VREF VSS nfet_03v3 w=4u l=0.28u
XCP8_0 TOPP BOTP8 cap_mim_2f0_m4m5_noshield c_width=5u c_length=5u
XCP8_1 TOPP BOTP8 cap_mim_2f0_m4m5_noshield c_width=5u c_length=5u
XCP8_2 TOPP BOTP8 cap_mim_2f0_m4m5_noshield c_width=5u c_length=5u
XCP8_3 TOPP BOTP8 cap_mim_2f0_m4m5_noshield c_width=5u c_length=5u
XCP7_0 TOPP BOTP7 cap_mim_2f0_m4m5_noshield c_width=5u c_length=5u
XCP7_1 TOPP BOTP7 cap_mim_2f0_m4m5_noshield c_width=5u c_length=5u
XCP6_0 TOPP BOTP6 cap_mim_2f0_m4m5_noshield c_width=5u c_length=5u
XCBP_0 LSBP TOPP cap_mim_2f0_m4m5_noshield c_width=5.04u c_length=5.04u
XCP5_0 LSBP BOTP5 cap_mim_2f0_m4m5_noshield c_width=29.37u c_length=29.37u
XCP4_0 LSBP BOTP4 cap_mim_2f0_m4m5_noshield c_width=20.695u c_length=20.695u
XCP3_0 LSBP BOTP3 cap_mim_2f0_m4m5_noshield c_width=14.565u c_length=14.565u
XCP2_0 LSBP BOTP2 cap_mim_2f0_m4m5_noshield c_width=10.23u c_length=10.23u
XCP1_0 LSBP BOTP1 cap_mim_2f0_m4m5_noshield c_width=7.165u c_length=7.165u
XCP0_0 LSBP BOTP0 cap_mim_2f0_m4m5_noshield c_width=5.0u c_length=5.0u
XCDP_0 LSBP VSS cap_mim_2f0_m4m5_noshield c_width=5u c_length=5u
XCN8_0 TOPN BOTN8 cap_mim_2f0_m4m5_noshield c_width=5u c_length=5u
XCN8_1 TOPN BOTN8 cap_mim_2f0_m4m5_noshield c_width=5u c_length=5u
XCN8_2 TOPN BOTN8 cap_mim_2f0_m4m5_noshield c_width=5u c_length=5u
XCN8_3 TOPN BOTN8 cap_mim_2f0_m4m5_noshield c_width=5u c_length=5u
XCN7_0 TOPN BOTN7 cap_mim_2f0_m4m5_noshield c_width=5u c_length=5u
XCN7_1 TOPN BOTN7 cap_mim_2f0_m4m5_noshield c_width=5u c_length=5u
XCN6_0 TOPN BOTN6 cap_mim_2f0_m4m5_noshield c_width=5u c_length=5u
XCBN_0 LSBN TOPN cap_mim_2f0_m4m5_noshield c_width=5.04u c_length=5.04u
XCN5_0 LSBN BOTN5 cap_mim_2f0_m4m5_noshield c_width=29.37u c_length=29.37u
XCN4_0 LSBN BOTN4 cap_mim_2f0_m4m5_noshield c_width=20.695u c_length=20.695u
XCN3_0 LSBN BOTN3 cap_mim_2f0_m4m5_noshield c_width=14.565u c_length=14.565u
XCN2_0 LSBN BOTN2 cap_mim_2f0_m4m5_noshield c_width=10.23u c_length=10.23u
XCN1_0 LSBN BOTN1 cap_mim_2f0_m4m5_noshield c_width=7.165u c_length=7.165u
XCN0_0 LSBN BOTN0 cap_mim_2f0_m4m5_noshield c_width=5.0u c_length=5.0u
XCDN_0 LSBN VSS cap_mim_2f0_m4m5_noshield c_width=5u c_length=5u
XCRNA_0 R SEB CR_m VSS nfet_03v3 w=5.0u l=0.28u
XCRNB_0 CR_m EN VSS VSS nfet_03v3 w=5.0u l=0.28u
XCRPA_0 R SEB VDD VDD pfet_03v3 w=5.0u l=0.28u
XCRPB_0 R EN VDD VDD pfet_03v3 w=5.0u l=0.28u
XCRBN_0 RB R VSS VSS nfet_03v3 w=2.5u l=0.28u
XCRBP_0 RB R VDD VDD pfet_03v3 w=5.0u l=0.28u
XDT1N0_0 DT1_0 SEN VSS VSS nfet_03v3 w=2.5u l=0.28u
XDT1P0_0 DT1_0 SEN VDD VDD pfet_03v3 w=5.0u l=0.28u
XDT1N1_0 SEN_d1 DT1_0 VSS VSS nfet_03v3 w=2.5u l=0.28u
XDT1P1_0 SEN_d1 DT1_0 VDD VDD pfet_03v3 w=5.0u l=0.28u
XOT1NA_0 TD1B SEN VSS VSS nfet_03v3 w=2.5u l=0.28u
XOT1NB_0 TD1B SEN_d1 VSS VSS nfet_03v3 w=2.5u l=0.28u
XOT1PA_0 OT1_m SEN VDD VDD pfet_03v3 w=10.0u l=0.28u
XOT1PB_0 TD1B SEN_d1 OT1_m VDD pfet_03v3 w=10.0u l=0.28u
XDT2N0_0 DT2_0 SEN_d1 VSS VSS nfet_03v3 w=2.5u l=0.28u
XDT2P0_0 DT2_0 SEN_d1 VDD VDD pfet_03v3 w=5.0u l=0.28u
XDT2N1_0 SEN_d2 DT2_0 VSS VSS nfet_03v3 w=2.5u l=0.28u
XDT2P1_0 SEN_d2 DT2_0 VDD VDD pfet_03v3 w=5.0u l=0.28u
XOT2NA_0 TD2B SEN VSS VSS nfet_03v3 w=2.5u l=0.28u
XOT2NB_0 TD2B SEN_d1 VSS VSS nfet_03v3 w=2.5u l=0.28u
XOT2NC_0 TD2B SEN_d2 VSS VSS nfet_03v3 w=2.5u l=0.28u
XOT2PA_0 OT2_m1 SEN VDD VDD pfet_03v3 w=15.0u l=0.28u
XOT2PB_0 OT2_m2 SEN_d1 OT2_m1 VDD pfet_03v3 w=15.0u l=0.28u
XOT2PC_0 TD2B SEN_d2 OT2_m2 VDD pfet_03v3 w=15.0u l=0.28u
XIT2N_0 TD2 TD2B VSS VSS nfet_03v3 w=2.5u l=0.28u
XIT2P_0 TD2 TD2B VDD VDD pfet_03v3 w=5.0u l=0.28u
XORNNA_0 RUN TD2 VSS VSS nfet_03v3 w=2.5u l=0.28u
XORNNB_0 RUN D9 VSS VSS nfet_03v3 w=2.5u l=0.28u
XORNNC_0 RUN ENB VSS VSS nfet_03v3 w=2.5u l=0.28u
XORNPA_0 ORN_m1 TD2 VDD VDD pfet_03v3 w=15.0u l=0.28u
XORNPB_0 ORN_m2 D9 ORN_m1 VDD pfet_03v3 w=15.0u l=0.28u
XORNPC_0 RUN ENB ORN_m2 VDD pfet_03v3 w=15.0u l=0.28u
XIRNN_0 RUNB RUN VSS VSS nfet_03v3 w=2.5u l=0.28u
XIRNP_0 RUNB RUN VDD VDD pfet_03v3 w=5.0u l=0.28u
XOVNA_0 VALIDB DP VSS VSS nfet_03v3 w=5.0u l=0.28u
XOVNB_0 VALIDB DN VSS VSS nfet_03v3 w=5.0u l=0.28u
XOVPA_0 OV_m DP VDD VDD pfet_03v3 w=20.0u l=0.28u
XOVPB_0 VALIDB DN OV_m VDD pfet_03v3 w=20.0u l=0.28u
XIVN_0 VALID VALIDB VSS VSS nfet_03v3 w=5.0u l=0.28u
XIVP_0 VALID VALIDB VDD VDD pfet_03v3 w=10.0u l=0.28u
XIDPN_0 DPB DP VSS VSS nfet_03v3 w=5.0u l=0.28u
XIDPP_0 DPB DP VDD VDD pfet_03v3 w=10.0u l=0.28u
XIDNN_0 DNB DN VSS VSS nfet_03v3 w=5.0u l=0.28u
XIDNP_0 DNB DN VDD VDD pfet_03v3 w=10.0u l=0.28u
XOKNA_0 CMPCLK VALID VSS VSS nfet_03v3 w=5.0u l=0.28u
XOKNB_0 CMPCLK RUNB VSS VSS nfet_03v3 w=5.0u l=0.28u
XOKPA_0 OK_m VALID VDD VDD pfet_03v3 w=20.0u l=0.28u
XOKPB_0 CMPCLK RUNB OK_m VDD pfet_03v3 w=20.0u l=0.28u
XIT0N_0 TEST0B TEST0 VSS VSS nfet_03v3 w=2.5u l=0.28u
XIT0P_0 TEST0B TEST0 VDD VDD pfet_03v3 w=5.0u l=0.28u
XIT1N_0 TEST1B TEST1 VSS VSS nfet_03v3 w=2.5u l=0.28u
XIT1P_0 TEST1B TEST1 VDD VDD pfet_03v3 w=5.0u l=0.28u
XOFPNA_0 FP TD1B VSS VSS nfet_03v3 w=2.5u l=0.28u
XOFPNB_0 FP TEST1B VSS VSS nfet_03v3 w=2.5u l=0.28u
XOFPNC_0 FP TEST0 VSS VSS nfet_03v3 w=2.5u l=0.28u
XOFPPA_0 OFP_m1 TD1B VDD VDD pfet_03v3 w=15.0u l=0.28u
XOFPPB_0 OFP_m2 TEST1B OFP_m1 VDD pfet_03v3 w=15.0u l=0.28u
XOFPPC_0 FP TEST0 OFP_m2 VDD pfet_03v3 w=15.0u l=0.28u
XOFNNA_0 FN TD1B VSS VSS nfet_03v3 w=2.5u l=0.28u
XOFNNB_0 FN TEST1B VSS VSS nfet_03v3 w=2.5u l=0.28u
XOFNNC_0 FN TEST0B VSS VSS nfet_03v3 w=2.5u l=0.28u
XOFNPA_0 OFN_m1 TD1B VDD VDD pfet_03v3 w=15.0u l=0.28u
XOFNPB_0 OFN_m2 TEST1B OFN_m1 VDD pfet_03v3 w=15.0u l=0.28u
XOFNPC_0 FN TEST0B OFN_m2 VDD pfet_03v3 w=15.0u l=0.28u
XK0_SNA_0 K0_SAB RUN K0_S_m VSS nfet_03v3 w=5.0u l=0.28u
XK0_SNB_0 K0_S_m VALIDB VSS VSS nfet_03v3 w=5.0u l=0.28u
XK0_SPA_0 K0_SAB RUN VDD VDD pfet_03v3 w=5.0u l=0.28u
XK0_SPB_0 K0_SAB VALIDB VDD VDD pfet_03v3 w=5.0u l=0.28u
XK0_LANA_0 K0_A K0_SAB K0_LA_m VSS nfet_03v3 w=5.0u l=0.28u
XK0_LANB_0 K0_LA_m K0_AB VSS VSS nfet_03v3 w=5.0u l=0.28u
XK0_LAPA_0 K0_A K0_SAB VDD VDD pfet_03v3 w=5.0u l=0.28u
XK0_LAPB_0 K0_A K0_AB VDD VDD pfet_03v3 w=5.0u l=0.28u
XK0_LBNA_0 K0_AB K0_A K0_LB_m VSS nfet_03v3 w=5.0u l=0.28u
XK0_LBNB_0 K0_LB_m RB VSS VSS nfet_03v3 w=5.0u l=0.28u
XK0_LBPA_0 K0_AB K0_A VDD VDD pfet_03v3 w=5.0u l=0.28u
XK0_LBPB_0 K0_AB RB VDD VDD pfet_03v3 w=5.0u l=0.28u
XK0_SPNA_0 K0_SETP K0_AB VSS VSS nfet_03v3 w=2.5u l=0.28u
XK0_SPNB_0 K0_SETP D0 VSS VSS nfet_03v3 w=2.5u l=0.28u
XK0_SPNC_0 K0_SETP DPB VSS VSS nfet_03v3 w=2.5u l=0.28u
XK0_SPPA_0 K0_SP_m1 K0_AB VDD VDD pfet_03v3 w=15.0u l=0.28u
XK0_SPPB_0 K0_SP_m2 D0 K0_SP_m1 VDD pfet_03v3 w=15.0u l=0.28u
XK0_SPPC_0 K0_SETP DPB K0_SP_m2 VDD pfet_03v3 w=15.0u l=0.28u
XK0_SNNA_0 K0_SETN K0_AB VSS VSS nfet_03v3 w=2.5u l=0.28u
XK0_SNNB_0 K0_SETN D0 VSS VSS nfet_03v3 w=2.5u l=0.28u
XK0_SNNC_0 K0_SETN DNB VSS VSS nfet_03v3 w=2.5u l=0.28u
XK0_SNPA_0 K0_SN_m1 K0_AB VDD VDD pfet_03v3 w=15.0u l=0.28u
XK0_SNPB_0 K0_SN_m2 D0 K0_SN_m1 VDD pfet_03v3 w=15.0u l=0.28u
XK0_SNPC_0 K0_SETN DNB K0_SN_m2 VDD pfet_03v3 w=15.0u l=0.28u
XK0_PANA_0 K0_QP R VSS VSS nfet_03v3 w=2.5u l=0.28u
XK0_PANB_0 K0_QP K0_QPB VSS VSS nfet_03v3 w=2.5u l=0.28u
XK0_PAPA_0 K0_PA_m R VDD VDD pfet_03v3 w=10.0u l=0.28u
XK0_PAPB_0 K0_QP K0_QPB K0_PA_m VDD pfet_03v3 w=10.0u l=0.28u
XK0_PBNA_0 K0_QPB K0_SETP VSS VSS nfet_03v3 w=2.5u l=0.28u
XK0_PBNB_0 K0_QPB K0_QP VSS VSS nfet_03v3 w=2.5u l=0.28u
XK0_PBPA_0 K0_PB_m K0_SETP VDD VDD pfet_03v3 w=10.0u l=0.28u
XK0_PBPB_0 K0_QPB K0_QP K0_PB_m VDD pfet_03v3 w=10.0u l=0.28u
XK0_NANA_0 K0_QN R VSS VSS nfet_03v3 w=2.5u l=0.28u
XK0_NANB_0 K0_QN K0_QNB VSS VSS nfet_03v3 w=2.5u l=0.28u
XK0_NAPA_0 K0_NA_m R VDD VDD pfet_03v3 w=10.0u l=0.28u
XK0_NAPB_0 K0_QN K0_QNB K0_NA_m VDD pfet_03v3 w=10.0u l=0.28u
XK0_NBNA_0 K0_QNB K0_SETN VSS VSS nfet_03v3 w=2.5u l=0.28u
XK0_NBNB_0 K0_QNB K0_QN VSS VSS nfet_03v3 w=2.5u l=0.28u
XK0_NBPA_0 K0_NB_m K0_SETN VDD VDD pfet_03v3 w=10.0u l=0.28u
XK0_NBPB_0 K0_QNB K0_QN K0_NB_m VDD pfet_03v3 w=10.0u l=0.28u
XK0_DNA_0 D0 K0_QPB K0_D_m VSS nfet_03v3 w=5.0u l=0.28u
XK0_DNB_0 K0_D_m K0_QNB VSS VSS nfet_03v3 w=5.0u l=0.28u
XK0_DPA_0 D0 K0_QPB VDD VDD pfet_03v3 w=5.0u l=0.28u
XK0_DPB_0 D0 K0_QNB VDD VDD pfet_03v3 w=5.0u l=0.28u
XDGP8N_0 GP8 K0_QPB VSS VSS nfet_03v3 w=5.0u l=0.28u
XDGP8P_0 GP8 K0_QPB VDD VDD pfet_03v3 w=10.0u l=0.28u
XDRP8N_0 RP8 K0_QP VSS VSS nfet_03v3 w=5.0u l=0.28u
XDRP8P_0 RP8 K0_QP VDD VDD pfet_03v3 w=10.0u l=0.28u
XDGN8N_0 GN8 K0_QNB VSS VSS nfet_03v3 w=5.0u l=0.28u
XDGN8P_0 GN8 K0_QNB VDD VDD pfet_03v3 w=10.0u l=0.28u
XDRN8N_0 RN8 K0_QN VSS VSS nfet_03v3 w=5.0u l=0.28u
XDRN8P_0 RN8 K0_QN VDD VDD pfet_03v3 w=10.0u l=0.28u
XK1_SNA_0 K1_SAB D0 K1_S_m VSS nfet_03v3 w=5.0u l=0.28u
XK1_SNB_0 K1_S_m VALIDB VSS VSS nfet_03v3 w=5.0u l=0.28u
XK1_SPA_0 K1_SAB D0 VDD VDD pfet_03v3 w=5.0u l=0.28u
XK1_SPB_0 K1_SAB VALIDB VDD VDD pfet_03v3 w=5.0u l=0.28u
XK1_LANA_0 K1_A K1_SAB K1_LA_m VSS nfet_03v3 w=5.0u l=0.28u
XK1_LANB_0 K1_LA_m K1_AB VSS VSS nfet_03v3 w=5.0u l=0.28u
XK1_LAPA_0 K1_A K1_SAB VDD VDD pfet_03v3 w=5.0u l=0.28u
XK1_LAPB_0 K1_A K1_AB VDD VDD pfet_03v3 w=5.0u l=0.28u
XK1_LBNA_0 K1_AB K1_A K1_LB_m VSS nfet_03v3 w=5.0u l=0.28u
XK1_LBNB_0 K1_LB_m RB VSS VSS nfet_03v3 w=5.0u l=0.28u
XK1_LBPA_0 K1_AB K1_A VDD VDD pfet_03v3 w=5.0u l=0.28u
XK1_LBPB_0 K1_AB RB VDD VDD pfet_03v3 w=5.0u l=0.28u
XK1_SPNA_0 K1_SETP K1_AB VSS VSS nfet_03v3 w=2.5u l=0.28u
XK1_SPNB_0 K1_SETP D1 VSS VSS nfet_03v3 w=2.5u l=0.28u
XK1_SPNC_0 K1_SETP DPB VSS VSS nfet_03v3 w=2.5u l=0.28u
XK1_SPPA_0 K1_SP_m1 K1_AB VDD VDD pfet_03v3 w=15.0u l=0.28u
XK1_SPPB_0 K1_SP_m2 D1 K1_SP_m1 VDD pfet_03v3 w=15.0u l=0.28u
XK1_SPPC_0 K1_SETP DPB K1_SP_m2 VDD pfet_03v3 w=15.0u l=0.28u
XK1_SNNA_0 K1_SETN K1_AB VSS VSS nfet_03v3 w=2.5u l=0.28u
XK1_SNNB_0 K1_SETN D1 VSS VSS nfet_03v3 w=2.5u l=0.28u
XK1_SNNC_0 K1_SETN DNB VSS VSS nfet_03v3 w=2.5u l=0.28u
XK1_SNPA_0 K1_SN_m1 K1_AB VDD VDD pfet_03v3 w=15.0u l=0.28u
XK1_SNPB_0 K1_SN_m2 D1 K1_SN_m1 VDD pfet_03v3 w=15.0u l=0.28u
XK1_SNPC_0 K1_SETN DNB K1_SN_m2 VDD pfet_03v3 w=15.0u l=0.28u
XK1_PANA_0 K1_QP R VSS VSS nfet_03v3 w=2.5u l=0.28u
XK1_PANB_0 K1_QP K1_QPB VSS VSS nfet_03v3 w=2.5u l=0.28u
XK1_PAPA_0 K1_PA_m R VDD VDD pfet_03v3 w=10.0u l=0.28u
XK1_PAPB_0 K1_QP K1_QPB K1_PA_m VDD pfet_03v3 w=10.0u l=0.28u
XK1_PBNA_0 K1_QPB K1_SETP VSS VSS nfet_03v3 w=2.5u l=0.28u
XK1_PBNB_0 K1_QPB K1_QP VSS VSS nfet_03v3 w=2.5u l=0.28u
XK1_PBPA_0 K1_PB_m K1_SETP VDD VDD pfet_03v3 w=10.0u l=0.28u
XK1_PBPB_0 K1_QPB K1_QP K1_PB_m VDD pfet_03v3 w=10.0u l=0.28u
XK1_NANA_0 K1_QN R VSS VSS nfet_03v3 w=2.5u l=0.28u
XK1_NANB_0 K1_QN K1_QNB VSS VSS nfet_03v3 w=2.5u l=0.28u
XK1_NAPA_0 K1_NA_m R VDD VDD pfet_03v3 w=10.0u l=0.28u
XK1_NAPB_0 K1_QN K1_QNB K1_NA_m VDD pfet_03v3 w=10.0u l=0.28u
XK1_NBNA_0 K1_QNB K1_SETN VSS VSS nfet_03v3 w=2.5u l=0.28u
XK1_NBNB_0 K1_QNB K1_QN VSS VSS nfet_03v3 w=2.5u l=0.28u
XK1_NBPA_0 K1_NB_m K1_SETN VDD VDD pfet_03v3 w=10.0u l=0.28u
XK1_NBPB_0 K1_QNB K1_QN K1_NB_m VDD pfet_03v3 w=10.0u l=0.28u
XK1_DNA_0 D1 K1_QPB K1_D_m VSS nfet_03v3 w=5.0u l=0.28u
XK1_DNB_0 K1_D_m K1_QNB VSS VSS nfet_03v3 w=5.0u l=0.28u
XK1_DPA_0 D1 K1_QPB VDD VDD pfet_03v3 w=5.0u l=0.28u
XK1_DPB_0 D1 K1_QNB VDD VDD pfet_03v3 w=5.0u l=0.28u
XDRP7NA_0 RP7 K1_QP VSS VSS nfet_03v3 w=2.5u l=0.28u
XDRP7NB_0 RP7 FP VSS VSS nfet_03v3 w=2.5u l=0.28u
XDRP7PA_0 DRP7_m K1_QP VDD VDD pfet_03v3 w=10.0u l=0.28u
XDRP7PB_0 RP7 FP DRP7_m VDD pfet_03v3 w=10.0u l=0.28u
XDGP7N_0 GP7 RP7 VSS VSS nfet_03v3 w=2.5u l=0.28u
XDGP7P_0 GP7 RP7 VDD VDD pfet_03v3 w=5.0u l=0.28u
XDRN7NA_0 RN7 K1_QN VSS VSS nfet_03v3 w=2.5u l=0.28u
XDRN7NB_0 RN7 FN VSS VSS nfet_03v3 w=2.5u l=0.28u
XDRN7PA_0 DRN7_m K1_QN VDD VDD pfet_03v3 w=10.0u l=0.28u
XDRN7PB_0 RN7 FN DRN7_m VDD pfet_03v3 w=10.0u l=0.28u
XDGN7N_0 GN7 RN7 VSS VSS nfet_03v3 w=2.5u l=0.28u
XDGN7P_0 GN7 RN7 VDD VDD pfet_03v3 w=5.0u l=0.28u
XK2_SNA_0 K2_SAB D1 K2_S_m VSS nfet_03v3 w=5.0u l=0.28u
XK2_SNB_0 K2_S_m VALIDB VSS VSS nfet_03v3 w=5.0u l=0.28u
XK2_SPA_0 K2_SAB D1 VDD VDD pfet_03v3 w=5.0u l=0.28u
XK2_SPB_0 K2_SAB VALIDB VDD VDD pfet_03v3 w=5.0u l=0.28u
XK2_LANA_0 K2_A K2_SAB K2_LA_m VSS nfet_03v3 w=5.0u l=0.28u
XK2_LANB_0 K2_LA_m K2_AB VSS VSS nfet_03v3 w=5.0u l=0.28u
XK2_LAPA_0 K2_A K2_SAB VDD VDD pfet_03v3 w=5.0u l=0.28u
XK2_LAPB_0 K2_A K2_AB VDD VDD pfet_03v3 w=5.0u l=0.28u
XK2_LBNA_0 K2_AB K2_A K2_LB_m VSS nfet_03v3 w=5.0u l=0.28u
XK2_LBNB_0 K2_LB_m RB VSS VSS nfet_03v3 w=5.0u l=0.28u
XK2_LBPA_0 K2_AB K2_A VDD VDD pfet_03v3 w=5.0u l=0.28u
XK2_LBPB_0 K2_AB RB VDD VDD pfet_03v3 w=5.0u l=0.28u
XK2_SPNA_0 K2_SETP K2_AB VSS VSS nfet_03v3 w=2.5u l=0.28u
XK2_SPNB_0 K2_SETP D2 VSS VSS nfet_03v3 w=2.5u l=0.28u
XK2_SPNC_0 K2_SETP DPB VSS VSS nfet_03v3 w=2.5u l=0.28u
XK2_SPPA_0 K2_SP_m1 K2_AB VDD VDD pfet_03v3 w=15.0u l=0.28u
XK2_SPPB_0 K2_SP_m2 D2 K2_SP_m1 VDD pfet_03v3 w=15.0u l=0.28u
XK2_SPPC_0 K2_SETP DPB K2_SP_m2 VDD pfet_03v3 w=15.0u l=0.28u
XK2_SNNA_0 K2_SETN K2_AB VSS VSS nfet_03v3 w=2.5u l=0.28u
XK2_SNNB_0 K2_SETN D2 VSS VSS nfet_03v3 w=2.5u l=0.28u
XK2_SNNC_0 K2_SETN DNB VSS VSS nfet_03v3 w=2.5u l=0.28u
XK2_SNPA_0 K2_SN_m1 K2_AB VDD VDD pfet_03v3 w=15.0u l=0.28u
XK2_SNPB_0 K2_SN_m2 D2 K2_SN_m1 VDD pfet_03v3 w=15.0u l=0.28u
XK2_SNPC_0 K2_SETN DNB K2_SN_m2 VDD pfet_03v3 w=15.0u l=0.28u
XK2_PANA_0 K2_QP R VSS VSS nfet_03v3 w=2.5u l=0.28u
XK2_PANB_0 K2_QP K2_QPB VSS VSS nfet_03v3 w=2.5u l=0.28u
XK2_PAPA_0 K2_PA_m R VDD VDD pfet_03v3 w=10.0u l=0.28u
XK2_PAPB_0 K2_QP K2_QPB K2_PA_m VDD pfet_03v3 w=10.0u l=0.28u
XK2_PBNA_0 K2_QPB K2_SETP VSS VSS nfet_03v3 w=2.5u l=0.28u
XK2_PBNB_0 K2_QPB K2_QP VSS VSS nfet_03v3 w=2.5u l=0.28u
XK2_PBPA_0 K2_PB_m K2_SETP VDD VDD pfet_03v3 w=10.0u l=0.28u
XK2_PBPB_0 K2_QPB K2_QP K2_PB_m VDD pfet_03v3 w=10.0u l=0.28u
XK2_NANA_0 K2_QN R VSS VSS nfet_03v3 w=2.5u l=0.28u
XK2_NANB_0 K2_QN K2_QNB VSS VSS nfet_03v3 w=2.5u l=0.28u
XK2_NAPA_0 K2_NA_m R VDD VDD pfet_03v3 w=10.0u l=0.28u
XK2_NAPB_0 K2_QN K2_QNB K2_NA_m VDD pfet_03v3 w=10.0u l=0.28u
XK2_NBNA_0 K2_QNB K2_SETN VSS VSS nfet_03v3 w=2.5u l=0.28u
XK2_NBNB_0 K2_QNB K2_QN VSS VSS nfet_03v3 w=2.5u l=0.28u
XK2_NBPA_0 K2_NB_m K2_SETN VDD VDD pfet_03v3 w=10.0u l=0.28u
XK2_NBPB_0 K2_QNB K2_QN K2_NB_m VDD pfet_03v3 w=10.0u l=0.28u
XK2_DNA_0 D2 K2_QPB K2_D_m VSS nfet_03v3 w=5.0u l=0.28u
XK2_DNB_0 K2_D_m K2_QNB VSS VSS nfet_03v3 w=5.0u l=0.28u
XK2_DPA_0 D2 K2_QPB VDD VDD pfet_03v3 w=5.0u l=0.28u
XK2_DPB_0 D2 K2_QNB VDD VDD pfet_03v3 w=5.0u l=0.28u
XDGP6N_0 GP6 K2_QPB VSS VSS nfet_03v3 w=2.5u l=0.28u
XDGP6P_0 GP6 K2_QPB VDD VDD pfet_03v3 w=5.0u l=0.28u
XDRP6N_0 RP6 K2_QP VSS VSS nfet_03v3 w=2.5u l=0.28u
XDRP6P_0 RP6 K2_QP VDD VDD pfet_03v3 w=5.0u l=0.28u
XDGN6N_0 GN6 K2_QNB VSS VSS nfet_03v3 w=2.5u l=0.28u
XDGN6P_0 GN6 K2_QNB VDD VDD pfet_03v3 w=5.0u l=0.28u
XDRN6N_0 RN6 K2_QN VSS VSS nfet_03v3 w=2.5u l=0.28u
XDRN6P_0 RN6 K2_QN VDD VDD pfet_03v3 w=5.0u l=0.28u
XK3_SNA_0 K3_SAB D2 K3_S_m VSS nfet_03v3 w=5.0u l=0.28u
XK3_SNB_0 K3_S_m VALIDB VSS VSS nfet_03v3 w=5.0u l=0.28u
XK3_SPA_0 K3_SAB D2 VDD VDD pfet_03v3 w=5.0u l=0.28u
XK3_SPB_0 K3_SAB VALIDB VDD VDD pfet_03v3 w=5.0u l=0.28u
XK3_LANA_0 K3_A K3_SAB K3_LA_m VSS nfet_03v3 w=5.0u l=0.28u
XK3_LANB_0 K3_LA_m K3_AB VSS VSS nfet_03v3 w=5.0u l=0.28u
XK3_LAPA_0 K3_A K3_SAB VDD VDD pfet_03v3 w=5.0u l=0.28u
XK3_LAPB_0 K3_A K3_AB VDD VDD pfet_03v3 w=5.0u l=0.28u
XK3_LBNA_0 K3_AB K3_A K3_LB_m VSS nfet_03v3 w=5.0u l=0.28u
XK3_LBNB_0 K3_LB_m RB VSS VSS nfet_03v3 w=5.0u l=0.28u
XK3_LBPA_0 K3_AB K3_A VDD VDD pfet_03v3 w=5.0u l=0.28u
XK3_LBPB_0 K3_AB RB VDD VDD pfet_03v3 w=5.0u l=0.28u
XK3_SPNA_0 K3_SETP K3_AB VSS VSS nfet_03v3 w=2.5u l=0.28u
XK3_SPNB_0 K3_SETP D3 VSS VSS nfet_03v3 w=2.5u l=0.28u
XK3_SPNC_0 K3_SETP DPB VSS VSS nfet_03v3 w=2.5u l=0.28u
XK3_SPPA_0 K3_SP_m1 K3_AB VDD VDD pfet_03v3 w=15.0u l=0.28u
XK3_SPPB_0 K3_SP_m2 D3 K3_SP_m1 VDD pfet_03v3 w=15.0u l=0.28u
XK3_SPPC_0 K3_SETP DPB K3_SP_m2 VDD pfet_03v3 w=15.0u l=0.28u
XK3_SNNA_0 K3_SETN K3_AB VSS VSS nfet_03v3 w=2.5u l=0.28u
XK3_SNNB_0 K3_SETN D3 VSS VSS nfet_03v3 w=2.5u l=0.28u
XK3_SNNC_0 K3_SETN DNB VSS VSS nfet_03v3 w=2.5u l=0.28u
XK3_SNPA_0 K3_SN_m1 K3_AB VDD VDD pfet_03v3 w=15.0u l=0.28u
XK3_SNPB_0 K3_SN_m2 D3 K3_SN_m1 VDD pfet_03v3 w=15.0u l=0.28u
XK3_SNPC_0 K3_SETN DNB K3_SN_m2 VDD pfet_03v3 w=15.0u l=0.28u
XK3_PANA_0 K3_QP R VSS VSS nfet_03v3 w=2.5u l=0.28u
XK3_PANB_0 K3_QP K3_QPB VSS VSS nfet_03v3 w=2.5u l=0.28u
XK3_PAPA_0 K3_PA_m R VDD VDD pfet_03v3 w=10.0u l=0.28u
XK3_PAPB_0 K3_QP K3_QPB K3_PA_m VDD pfet_03v3 w=10.0u l=0.28u
XK3_PBNA_0 K3_QPB K3_SETP VSS VSS nfet_03v3 w=2.5u l=0.28u
XK3_PBNB_0 K3_QPB K3_QP VSS VSS nfet_03v3 w=2.5u l=0.28u
XK3_PBPA_0 K3_PB_m K3_SETP VDD VDD pfet_03v3 w=10.0u l=0.28u
XK3_PBPB_0 K3_QPB K3_QP K3_PB_m VDD pfet_03v3 w=10.0u l=0.28u
XK3_NANA_0 K3_QN R VSS VSS nfet_03v3 w=2.5u l=0.28u
XK3_NANB_0 K3_QN K3_QNB VSS VSS nfet_03v3 w=2.5u l=0.28u
XK3_NAPA_0 K3_NA_m R VDD VDD pfet_03v3 w=10.0u l=0.28u
XK3_NAPB_0 K3_QN K3_QNB K3_NA_m VDD pfet_03v3 w=10.0u l=0.28u
XK3_NBNA_0 K3_QNB K3_SETN VSS VSS nfet_03v3 w=2.5u l=0.28u
XK3_NBNB_0 K3_QNB K3_QN VSS VSS nfet_03v3 w=2.5u l=0.28u
XK3_NBPA_0 K3_NB_m K3_SETN VDD VDD pfet_03v3 w=10.0u l=0.28u
XK3_NBPB_0 K3_QNB K3_QN K3_NB_m VDD pfet_03v3 w=10.0u l=0.28u
XK3_DNA_0 D3 K3_QPB K3_D_m VSS nfet_03v3 w=5.0u l=0.28u
XK3_DNB_0 K3_D_m K3_QNB VSS VSS nfet_03v3 w=5.0u l=0.28u
XK3_DPA_0 D3 K3_QPB VDD VDD pfet_03v3 w=5.0u l=0.28u
XK3_DPB_0 D3 K3_QNB VDD VDD pfet_03v3 w=5.0u l=0.28u
XDGP5N_0 GP5 K3_QPB VSS VSS nfet_03v3 w=5.0u l=0.28u
XDGP5P_0 GP5 K3_QPB VDD VDD pfet_03v3 w=10.0u l=0.28u
XDRP5N_0 RP5 K3_QP VSS VSS nfet_03v3 w=5.0u l=0.28u
XDRP5P_0 RP5 K3_QP VDD VDD pfet_03v3 w=10.0u l=0.28u
XDGN5N_0 GN5 K3_QNB VSS VSS nfet_03v3 w=5.0u l=0.28u
XDGN5P_0 GN5 K3_QNB VDD VDD pfet_03v3 w=10.0u l=0.28u
XDRN5N_0 RN5 K3_QN VSS VSS nfet_03v3 w=5.0u l=0.28u
XDRN5P_0 RN5 K3_QN VDD VDD pfet_03v3 w=10.0u l=0.28u
XK4_SNA_0 K4_SAB D3 K4_S_m VSS nfet_03v3 w=5.0u l=0.28u
XK4_SNB_0 K4_S_m VALIDB VSS VSS nfet_03v3 w=5.0u l=0.28u
XK4_SPA_0 K4_SAB D3 VDD VDD pfet_03v3 w=5.0u l=0.28u
XK4_SPB_0 K4_SAB VALIDB VDD VDD pfet_03v3 w=5.0u l=0.28u
XK4_LANA_0 K4_A K4_SAB K4_LA_m VSS nfet_03v3 w=5.0u l=0.28u
XK4_LANB_0 K4_LA_m K4_AB VSS VSS nfet_03v3 w=5.0u l=0.28u
XK4_LAPA_0 K4_A K4_SAB VDD VDD pfet_03v3 w=5.0u l=0.28u
XK4_LAPB_0 K4_A K4_AB VDD VDD pfet_03v3 w=5.0u l=0.28u
XK4_LBNA_0 K4_AB K4_A K4_LB_m VSS nfet_03v3 w=5.0u l=0.28u
XK4_LBNB_0 K4_LB_m RB VSS VSS nfet_03v3 w=5.0u l=0.28u
XK4_LBPA_0 K4_AB K4_A VDD VDD pfet_03v3 w=5.0u l=0.28u
XK4_LBPB_0 K4_AB RB VDD VDD pfet_03v3 w=5.0u l=0.28u
XK4_SPNA_0 K4_SETP K4_AB VSS VSS nfet_03v3 w=2.5u l=0.28u
XK4_SPNB_0 K4_SETP D4 VSS VSS nfet_03v3 w=2.5u l=0.28u
XK4_SPNC_0 K4_SETP DPB VSS VSS nfet_03v3 w=2.5u l=0.28u
XK4_SPPA_0 K4_SP_m1 K4_AB VDD VDD pfet_03v3 w=15.0u l=0.28u
XK4_SPPB_0 K4_SP_m2 D4 K4_SP_m1 VDD pfet_03v3 w=15.0u l=0.28u
XK4_SPPC_0 K4_SETP DPB K4_SP_m2 VDD pfet_03v3 w=15.0u l=0.28u
XK4_SNNA_0 K4_SETN K4_AB VSS VSS nfet_03v3 w=2.5u l=0.28u
XK4_SNNB_0 K4_SETN D4 VSS VSS nfet_03v3 w=2.5u l=0.28u
XK4_SNNC_0 K4_SETN DNB VSS VSS nfet_03v3 w=2.5u l=0.28u
XK4_SNPA_0 K4_SN_m1 K4_AB VDD VDD pfet_03v3 w=15.0u l=0.28u
XK4_SNPB_0 K4_SN_m2 D4 K4_SN_m1 VDD pfet_03v3 w=15.0u l=0.28u
XK4_SNPC_0 K4_SETN DNB K4_SN_m2 VDD pfet_03v3 w=15.0u l=0.28u
XK4_PANA_0 K4_QP R VSS VSS nfet_03v3 w=2.5u l=0.28u
XK4_PANB_0 K4_QP K4_QPB VSS VSS nfet_03v3 w=2.5u l=0.28u
XK4_PAPA_0 K4_PA_m R VDD VDD pfet_03v3 w=10.0u l=0.28u
XK4_PAPB_0 K4_QP K4_QPB K4_PA_m VDD pfet_03v3 w=10.0u l=0.28u
XK4_PBNA_0 K4_QPB K4_SETP VSS VSS nfet_03v3 w=2.5u l=0.28u
XK4_PBNB_0 K4_QPB K4_QP VSS VSS nfet_03v3 w=2.5u l=0.28u
XK4_PBPA_0 K4_PB_m K4_SETP VDD VDD pfet_03v3 w=10.0u l=0.28u
XK4_PBPB_0 K4_QPB K4_QP K4_PB_m VDD pfet_03v3 w=10.0u l=0.28u
XK4_NANA_0 K4_QN R VSS VSS nfet_03v3 w=2.5u l=0.28u
XK4_NANB_0 K4_QN K4_QNB VSS VSS nfet_03v3 w=2.5u l=0.28u
XK4_NAPA_0 K4_NA_m R VDD VDD pfet_03v3 w=10.0u l=0.28u
XK4_NAPB_0 K4_QN K4_QNB K4_NA_m VDD pfet_03v3 w=10.0u l=0.28u
XK4_NBNA_0 K4_QNB K4_SETN VSS VSS nfet_03v3 w=2.5u l=0.28u
XK4_NBNB_0 K4_QNB K4_QN VSS VSS nfet_03v3 w=2.5u l=0.28u
XK4_NBPA_0 K4_NB_m K4_SETN VDD VDD pfet_03v3 w=10.0u l=0.28u
XK4_NBPB_0 K4_QNB K4_QN K4_NB_m VDD pfet_03v3 w=10.0u l=0.28u
XK4_DNA_0 D4 K4_QPB K4_D_m VSS nfet_03v3 w=5.0u l=0.28u
XK4_DNB_0 K4_D_m K4_QNB VSS VSS nfet_03v3 w=5.0u l=0.28u
XK4_DPA_0 D4 K4_QPB VDD VDD pfet_03v3 w=5.0u l=0.28u
XK4_DPB_0 D4 K4_QNB VDD VDD pfet_03v3 w=5.0u l=0.28u
XDGP4N_0 GP4 K4_QPB VSS VSS nfet_03v3 w=5.0u l=0.28u
XDGP4P_0 GP4 K4_QPB VDD VDD pfet_03v3 w=10.0u l=0.28u
XDRP4N_0 RP4 K4_QP VSS VSS nfet_03v3 w=5.0u l=0.28u
XDRP4P_0 RP4 K4_QP VDD VDD pfet_03v3 w=10.0u l=0.28u
XDGN4N_0 GN4 K4_QNB VSS VSS nfet_03v3 w=5.0u l=0.28u
XDGN4P_0 GN4 K4_QNB VDD VDD pfet_03v3 w=10.0u l=0.28u
XDRN4N_0 RN4 K4_QN VSS VSS nfet_03v3 w=5.0u l=0.28u
XDRN4P_0 RN4 K4_QN VDD VDD pfet_03v3 w=10.0u l=0.28u
XK5_SNA_0 K5_SAB D4 K5_S_m VSS nfet_03v3 w=5.0u l=0.28u
XK5_SNB_0 K5_S_m VALIDB VSS VSS nfet_03v3 w=5.0u l=0.28u
XK5_SPA_0 K5_SAB D4 VDD VDD pfet_03v3 w=5.0u l=0.28u
XK5_SPB_0 K5_SAB VALIDB VDD VDD pfet_03v3 w=5.0u l=0.28u
XK5_LANA_0 K5_A K5_SAB K5_LA_m VSS nfet_03v3 w=5.0u l=0.28u
XK5_LANB_0 K5_LA_m K5_AB VSS VSS nfet_03v3 w=5.0u l=0.28u
XK5_LAPA_0 K5_A K5_SAB VDD VDD pfet_03v3 w=5.0u l=0.28u
XK5_LAPB_0 K5_A K5_AB VDD VDD pfet_03v3 w=5.0u l=0.28u
XK5_LBNA_0 K5_AB K5_A K5_LB_m VSS nfet_03v3 w=5.0u l=0.28u
XK5_LBNB_0 K5_LB_m RB VSS VSS nfet_03v3 w=5.0u l=0.28u
XK5_LBPA_0 K5_AB K5_A VDD VDD pfet_03v3 w=5.0u l=0.28u
XK5_LBPB_0 K5_AB RB VDD VDD pfet_03v3 w=5.0u l=0.28u
XK5_SPNA_0 K5_SETP K5_AB VSS VSS nfet_03v3 w=2.5u l=0.28u
XK5_SPNB_0 K5_SETP D5 VSS VSS nfet_03v3 w=2.5u l=0.28u
XK5_SPNC_0 K5_SETP DPB VSS VSS nfet_03v3 w=2.5u l=0.28u
XK5_SPPA_0 K5_SP_m1 K5_AB VDD VDD pfet_03v3 w=15.0u l=0.28u
XK5_SPPB_0 K5_SP_m2 D5 K5_SP_m1 VDD pfet_03v3 w=15.0u l=0.28u
XK5_SPPC_0 K5_SETP DPB K5_SP_m2 VDD pfet_03v3 w=15.0u l=0.28u
XK5_SNNA_0 K5_SETN K5_AB VSS VSS nfet_03v3 w=2.5u l=0.28u
XK5_SNNB_0 K5_SETN D5 VSS VSS nfet_03v3 w=2.5u l=0.28u
XK5_SNNC_0 K5_SETN DNB VSS VSS nfet_03v3 w=2.5u l=0.28u
XK5_SNPA_0 K5_SN_m1 K5_AB VDD VDD pfet_03v3 w=15.0u l=0.28u
XK5_SNPB_0 K5_SN_m2 D5 K5_SN_m1 VDD pfet_03v3 w=15.0u l=0.28u
XK5_SNPC_0 K5_SETN DNB K5_SN_m2 VDD pfet_03v3 w=15.0u l=0.28u
XK5_PANA_0 K5_QP R VSS VSS nfet_03v3 w=2.5u l=0.28u
XK5_PANB_0 K5_QP K5_QPB VSS VSS nfet_03v3 w=2.5u l=0.28u
XK5_PAPA_0 K5_PA_m R VDD VDD pfet_03v3 w=10.0u l=0.28u
XK5_PAPB_0 K5_QP K5_QPB K5_PA_m VDD pfet_03v3 w=10.0u l=0.28u
XK5_PBNA_0 K5_QPB K5_SETP VSS VSS nfet_03v3 w=2.5u l=0.28u
XK5_PBNB_0 K5_QPB K5_QP VSS VSS nfet_03v3 w=2.5u l=0.28u
XK5_PBPA_0 K5_PB_m K5_SETP VDD VDD pfet_03v3 w=10.0u l=0.28u
XK5_PBPB_0 K5_QPB K5_QP K5_PB_m VDD pfet_03v3 w=10.0u l=0.28u
XK5_NANA_0 K5_QN R VSS VSS nfet_03v3 w=2.5u l=0.28u
XK5_NANB_0 K5_QN K5_QNB VSS VSS nfet_03v3 w=2.5u l=0.28u
XK5_NAPA_0 K5_NA_m R VDD VDD pfet_03v3 w=10.0u l=0.28u
XK5_NAPB_0 K5_QN K5_QNB K5_NA_m VDD pfet_03v3 w=10.0u l=0.28u
XK5_NBNA_0 K5_QNB K5_SETN VSS VSS nfet_03v3 w=2.5u l=0.28u
XK5_NBNB_0 K5_QNB K5_QN VSS VSS nfet_03v3 w=2.5u l=0.28u
XK5_NBPA_0 K5_NB_m K5_SETN VDD VDD pfet_03v3 w=10.0u l=0.28u
XK5_NBPB_0 K5_QNB K5_QN K5_NB_m VDD pfet_03v3 w=10.0u l=0.28u
XK5_DNA_0 D5 K5_QPB K5_D_m VSS nfet_03v3 w=5.0u l=0.28u
XK5_DNB_0 K5_D_m K5_QNB VSS VSS nfet_03v3 w=5.0u l=0.28u
XK5_DPA_0 D5 K5_QPB VDD VDD pfet_03v3 w=5.0u l=0.28u
XK5_DPB_0 D5 K5_QNB VDD VDD pfet_03v3 w=5.0u l=0.28u
XDGP3N_0 GP3 K5_QPB VSS VSS nfet_03v3 w=2.5u l=0.28u
XDGP3P_0 GP3 K5_QPB VDD VDD pfet_03v3 w=5.0u l=0.28u
XDRP3N_0 RP3 K5_QP VSS VSS nfet_03v3 w=2.5u l=0.28u
XDRP3P_0 RP3 K5_QP VDD VDD pfet_03v3 w=5.0u l=0.28u
XDGN3N_0 GN3 K5_QNB VSS VSS nfet_03v3 w=2.5u l=0.28u
XDGN3P_0 GN3 K5_QNB VDD VDD pfet_03v3 w=5.0u l=0.28u
XDRN3N_0 RN3 K5_QN VSS VSS nfet_03v3 w=2.5u l=0.28u
XDRN3P_0 RN3 K5_QN VDD VDD pfet_03v3 w=5.0u l=0.28u
XK6_SNA_0 K6_SAB D5 K6_S_m VSS nfet_03v3 w=5.0u l=0.28u
XK6_SNB_0 K6_S_m VALIDB VSS VSS nfet_03v3 w=5.0u l=0.28u
XK6_SPA_0 K6_SAB D5 VDD VDD pfet_03v3 w=5.0u l=0.28u
XK6_SPB_0 K6_SAB VALIDB VDD VDD pfet_03v3 w=5.0u l=0.28u
XK6_LANA_0 K6_A K6_SAB K6_LA_m VSS nfet_03v3 w=5.0u l=0.28u
XK6_LANB_0 K6_LA_m K6_AB VSS VSS nfet_03v3 w=5.0u l=0.28u
XK6_LAPA_0 K6_A K6_SAB VDD VDD pfet_03v3 w=5.0u l=0.28u
XK6_LAPB_0 K6_A K6_AB VDD VDD pfet_03v3 w=5.0u l=0.28u
XK6_LBNA_0 K6_AB K6_A K6_LB_m VSS nfet_03v3 w=5.0u l=0.28u
XK6_LBNB_0 K6_LB_m RB VSS VSS nfet_03v3 w=5.0u l=0.28u
XK6_LBPA_0 K6_AB K6_A VDD VDD pfet_03v3 w=5.0u l=0.28u
XK6_LBPB_0 K6_AB RB VDD VDD pfet_03v3 w=5.0u l=0.28u
XK6_SPNA_0 K6_SETP K6_AB VSS VSS nfet_03v3 w=2.5u l=0.28u
XK6_SPNB_0 K6_SETP D6 VSS VSS nfet_03v3 w=2.5u l=0.28u
XK6_SPNC_0 K6_SETP DPB VSS VSS nfet_03v3 w=2.5u l=0.28u
XK6_SPPA_0 K6_SP_m1 K6_AB VDD VDD pfet_03v3 w=15.0u l=0.28u
XK6_SPPB_0 K6_SP_m2 D6 K6_SP_m1 VDD pfet_03v3 w=15.0u l=0.28u
XK6_SPPC_0 K6_SETP DPB K6_SP_m2 VDD pfet_03v3 w=15.0u l=0.28u
XK6_SNNA_0 K6_SETN K6_AB VSS VSS nfet_03v3 w=2.5u l=0.28u
XK6_SNNB_0 K6_SETN D6 VSS VSS nfet_03v3 w=2.5u l=0.28u
XK6_SNNC_0 K6_SETN DNB VSS VSS nfet_03v3 w=2.5u l=0.28u
XK6_SNPA_0 K6_SN_m1 K6_AB VDD VDD pfet_03v3 w=15.0u l=0.28u
XK6_SNPB_0 K6_SN_m2 D6 K6_SN_m1 VDD pfet_03v3 w=15.0u l=0.28u
XK6_SNPC_0 K6_SETN DNB K6_SN_m2 VDD pfet_03v3 w=15.0u l=0.28u
XK6_PANA_0 K6_QP R VSS VSS nfet_03v3 w=2.5u l=0.28u
XK6_PANB_0 K6_QP K6_QPB VSS VSS nfet_03v3 w=2.5u l=0.28u
XK6_PAPA_0 K6_PA_m R VDD VDD pfet_03v3 w=10.0u l=0.28u
XK6_PAPB_0 K6_QP K6_QPB K6_PA_m VDD pfet_03v3 w=10.0u l=0.28u
XK6_PBNA_0 K6_QPB K6_SETP VSS VSS nfet_03v3 w=2.5u l=0.28u
XK6_PBNB_0 K6_QPB K6_QP VSS VSS nfet_03v3 w=2.5u l=0.28u
XK6_PBPA_0 K6_PB_m K6_SETP VDD VDD pfet_03v3 w=10.0u l=0.28u
XK6_PBPB_0 K6_QPB K6_QP K6_PB_m VDD pfet_03v3 w=10.0u l=0.28u
XK6_NANA_0 K6_QN R VSS VSS nfet_03v3 w=2.5u l=0.28u
XK6_NANB_0 K6_QN K6_QNB VSS VSS nfet_03v3 w=2.5u l=0.28u
XK6_NAPA_0 K6_NA_m R VDD VDD pfet_03v3 w=10.0u l=0.28u
XK6_NAPB_0 K6_QN K6_QNB K6_NA_m VDD pfet_03v3 w=10.0u l=0.28u
XK6_NBNA_0 K6_QNB K6_SETN VSS VSS nfet_03v3 w=2.5u l=0.28u
XK6_NBNB_0 K6_QNB K6_QN VSS VSS nfet_03v3 w=2.5u l=0.28u
XK6_NBPA_0 K6_NB_m K6_SETN VDD VDD pfet_03v3 w=10.0u l=0.28u
XK6_NBPB_0 K6_QNB K6_QN K6_NB_m VDD pfet_03v3 w=10.0u l=0.28u
XK6_DNA_0 D6 K6_QPB K6_D_m VSS nfet_03v3 w=5.0u l=0.28u
XK6_DNB_0 K6_D_m K6_QNB VSS VSS nfet_03v3 w=5.0u l=0.28u
XK6_DPA_0 D6 K6_QPB VDD VDD pfet_03v3 w=5.0u l=0.28u
XK6_DPB_0 D6 K6_QNB VDD VDD pfet_03v3 w=5.0u l=0.28u
XDGP2N_0 GP2 K6_QPB VSS VSS nfet_03v3 w=2.5u l=0.28u
XDGP2P_0 GP2 K6_QPB VDD VDD pfet_03v3 w=5.0u l=0.28u
XDRP2N_0 RP2 K6_QP VSS VSS nfet_03v3 w=2.5u l=0.28u
XDRP2P_0 RP2 K6_QP VDD VDD pfet_03v3 w=5.0u l=0.28u
XDGN2N_0 GN2 K6_QNB VSS VSS nfet_03v3 w=2.5u l=0.28u
XDGN2P_0 GN2 K6_QNB VDD VDD pfet_03v3 w=5.0u l=0.28u
XDRN2N_0 RN2 K6_QN VSS VSS nfet_03v3 w=2.5u l=0.28u
XDRN2P_0 RN2 K6_QN VDD VDD pfet_03v3 w=5.0u l=0.28u
XK7_SNA_0 K7_SAB D6 K7_S_m VSS nfet_03v3 w=5.0u l=0.28u
XK7_SNB_0 K7_S_m VALIDB VSS VSS nfet_03v3 w=5.0u l=0.28u
XK7_SPA_0 K7_SAB D6 VDD VDD pfet_03v3 w=5.0u l=0.28u
XK7_SPB_0 K7_SAB VALIDB VDD VDD pfet_03v3 w=5.0u l=0.28u
XK7_LANA_0 K7_A K7_SAB K7_LA_m VSS nfet_03v3 w=5.0u l=0.28u
XK7_LANB_0 K7_LA_m K7_AB VSS VSS nfet_03v3 w=5.0u l=0.28u
XK7_LAPA_0 K7_A K7_SAB VDD VDD pfet_03v3 w=5.0u l=0.28u
XK7_LAPB_0 K7_A K7_AB VDD VDD pfet_03v3 w=5.0u l=0.28u
XK7_LBNA_0 K7_AB K7_A K7_LB_m VSS nfet_03v3 w=5.0u l=0.28u
XK7_LBNB_0 K7_LB_m RB VSS VSS nfet_03v3 w=5.0u l=0.28u
XK7_LBPA_0 K7_AB K7_A VDD VDD pfet_03v3 w=5.0u l=0.28u
XK7_LBPB_0 K7_AB RB VDD VDD pfet_03v3 w=5.0u l=0.28u
XK7_SPNA_0 K7_SETP K7_AB VSS VSS nfet_03v3 w=2.5u l=0.28u
XK7_SPNB_0 K7_SETP D7 VSS VSS nfet_03v3 w=2.5u l=0.28u
XK7_SPNC_0 K7_SETP DPB VSS VSS nfet_03v3 w=2.5u l=0.28u
XK7_SPPA_0 K7_SP_m1 K7_AB VDD VDD pfet_03v3 w=15.0u l=0.28u
XK7_SPPB_0 K7_SP_m2 D7 K7_SP_m1 VDD pfet_03v3 w=15.0u l=0.28u
XK7_SPPC_0 K7_SETP DPB K7_SP_m2 VDD pfet_03v3 w=15.0u l=0.28u
XK7_SNNA_0 K7_SETN K7_AB VSS VSS nfet_03v3 w=2.5u l=0.28u
XK7_SNNB_0 K7_SETN D7 VSS VSS nfet_03v3 w=2.5u l=0.28u
XK7_SNNC_0 K7_SETN DNB VSS VSS nfet_03v3 w=2.5u l=0.28u
XK7_SNPA_0 K7_SN_m1 K7_AB VDD VDD pfet_03v3 w=15.0u l=0.28u
XK7_SNPB_0 K7_SN_m2 D7 K7_SN_m1 VDD pfet_03v3 w=15.0u l=0.28u
XK7_SNPC_0 K7_SETN DNB K7_SN_m2 VDD pfet_03v3 w=15.0u l=0.28u
XK7_PANA_0 K7_QP R VSS VSS nfet_03v3 w=2.5u l=0.28u
XK7_PANB_0 K7_QP K7_QPB VSS VSS nfet_03v3 w=2.5u l=0.28u
XK7_PAPA_0 K7_PA_m R VDD VDD pfet_03v3 w=10.0u l=0.28u
XK7_PAPB_0 K7_QP K7_QPB K7_PA_m VDD pfet_03v3 w=10.0u l=0.28u
XK7_PBNA_0 K7_QPB K7_SETP VSS VSS nfet_03v3 w=2.5u l=0.28u
XK7_PBNB_0 K7_QPB K7_QP VSS VSS nfet_03v3 w=2.5u l=0.28u
XK7_PBPA_0 K7_PB_m K7_SETP VDD VDD pfet_03v3 w=10.0u l=0.28u
XK7_PBPB_0 K7_QPB K7_QP K7_PB_m VDD pfet_03v3 w=10.0u l=0.28u
XK7_NANA_0 K7_QN R VSS VSS nfet_03v3 w=2.5u l=0.28u
XK7_NANB_0 K7_QN K7_QNB VSS VSS nfet_03v3 w=2.5u l=0.28u
XK7_NAPA_0 K7_NA_m R VDD VDD pfet_03v3 w=10.0u l=0.28u
XK7_NAPB_0 K7_QN K7_QNB K7_NA_m VDD pfet_03v3 w=10.0u l=0.28u
XK7_NBNA_0 K7_QNB K7_SETN VSS VSS nfet_03v3 w=2.5u l=0.28u
XK7_NBNB_0 K7_QNB K7_QN VSS VSS nfet_03v3 w=2.5u l=0.28u
XK7_NBPA_0 K7_NB_m K7_SETN VDD VDD pfet_03v3 w=10.0u l=0.28u
XK7_NBPB_0 K7_QNB K7_QN K7_NB_m VDD pfet_03v3 w=10.0u l=0.28u
XK7_DNA_0 D7 K7_QPB K7_D_m VSS nfet_03v3 w=5.0u l=0.28u
XK7_DNB_0 K7_D_m K7_QNB VSS VSS nfet_03v3 w=5.0u l=0.28u
XK7_DPA_0 D7 K7_QPB VDD VDD pfet_03v3 w=5.0u l=0.28u
XK7_DPB_0 D7 K7_QNB VDD VDD pfet_03v3 w=5.0u l=0.28u
XDGP1N_0 GP1 K7_QPB VSS VSS nfet_03v3 w=2.5u l=0.28u
XDGP1P_0 GP1 K7_QPB VDD VDD pfet_03v3 w=5.0u l=0.28u
XDRP1N_0 RP1 K7_QP VSS VSS nfet_03v3 w=2.5u l=0.28u
XDRP1P_0 RP1 K7_QP VDD VDD pfet_03v3 w=5.0u l=0.28u
XDGN1N_0 GN1 K7_QNB VSS VSS nfet_03v3 w=2.5u l=0.28u
XDGN1P_0 GN1 K7_QNB VDD VDD pfet_03v3 w=5.0u l=0.28u
XDRN1N_0 RN1 K7_QN VSS VSS nfet_03v3 w=2.5u l=0.28u
XDRN1P_0 RN1 K7_QN VDD VDD pfet_03v3 w=5.0u l=0.28u
XK8_SNA_0 K8_SAB D7 K8_S_m VSS nfet_03v3 w=5.0u l=0.28u
XK8_SNB_0 K8_S_m VALIDB VSS VSS nfet_03v3 w=5.0u l=0.28u
XK8_SPA_0 K8_SAB D7 VDD VDD pfet_03v3 w=5.0u l=0.28u
XK8_SPB_0 K8_SAB VALIDB VDD VDD pfet_03v3 w=5.0u l=0.28u
XK8_LANA_0 K8_A K8_SAB K8_LA_m VSS nfet_03v3 w=5.0u l=0.28u
XK8_LANB_0 K8_LA_m K8_AB VSS VSS nfet_03v3 w=5.0u l=0.28u
XK8_LAPA_0 K8_A K8_SAB VDD VDD pfet_03v3 w=5.0u l=0.28u
XK8_LAPB_0 K8_A K8_AB VDD VDD pfet_03v3 w=5.0u l=0.28u
XK8_LBNA_0 K8_AB K8_A K8_LB_m VSS nfet_03v3 w=5.0u l=0.28u
XK8_LBNB_0 K8_LB_m RB VSS VSS nfet_03v3 w=5.0u l=0.28u
XK8_LBPA_0 K8_AB K8_A VDD VDD pfet_03v3 w=5.0u l=0.28u
XK8_LBPB_0 K8_AB RB VDD VDD pfet_03v3 w=5.0u l=0.28u
XK8_SPNA_0 K8_SETP K8_AB VSS VSS nfet_03v3 w=2.5u l=0.28u
XK8_SPNB_0 K8_SETP D8 VSS VSS nfet_03v3 w=2.5u l=0.28u
XK8_SPNC_0 K8_SETP DPB VSS VSS nfet_03v3 w=2.5u l=0.28u
XK8_SPPA_0 K8_SP_m1 K8_AB VDD VDD pfet_03v3 w=15.0u l=0.28u
XK8_SPPB_0 K8_SP_m2 D8 K8_SP_m1 VDD pfet_03v3 w=15.0u l=0.28u
XK8_SPPC_0 K8_SETP DPB K8_SP_m2 VDD pfet_03v3 w=15.0u l=0.28u
XK8_SNNA_0 K8_SETN K8_AB VSS VSS nfet_03v3 w=2.5u l=0.28u
XK8_SNNB_0 K8_SETN D8 VSS VSS nfet_03v3 w=2.5u l=0.28u
XK8_SNNC_0 K8_SETN DNB VSS VSS nfet_03v3 w=2.5u l=0.28u
XK8_SNPA_0 K8_SN_m1 K8_AB VDD VDD pfet_03v3 w=15.0u l=0.28u
XK8_SNPB_0 K8_SN_m2 D8 K8_SN_m1 VDD pfet_03v3 w=15.0u l=0.28u
XK8_SNPC_0 K8_SETN DNB K8_SN_m2 VDD pfet_03v3 w=15.0u l=0.28u
XK8_PANA_0 K8_QP R VSS VSS nfet_03v3 w=2.5u l=0.28u
XK8_PANB_0 K8_QP K8_QPB VSS VSS nfet_03v3 w=2.5u l=0.28u
XK8_PAPA_0 K8_PA_m R VDD VDD pfet_03v3 w=10.0u l=0.28u
XK8_PAPB_0 K8_QP K8_QPB K8_PA_m VDD pfet_03v3 w=10.0u l=0.28u
XK8_PBNA_0 K8_QPB K8_SETP VSS VSS nfet_03v3 w=2.5u l=0.28u
XK8_PBNB_0 K8_QPB K8_QP VSS VSS nfet_03v3 w=2.5u l=0.28u
XK8_PBPA_0 K8_PB_m K8_SETP VDD VDD pfet_03v3 w=10.0u l=0.28u
XK8_PBPB_0 K8_QPB K8_QP K8_PB_m VDD pfet_03v3 w=10.0u l=0.28u
XK8_NANA_0 K8_QN R VSS VSS nfet_03v3 w=2.5u l=0.28u
XK8_NANB_0 K8_QN K8_QNB VSS VSS nfet_03v3 w=2.5u l=0.28u
XK8_NAPA_0 K8_NA_m R VDD VDD pfet_03v3 w=10.0u l=0.28u
XK8_NAPB_0 K8_QN K8_QNB K8_NA_m VDD pfet_03v3 w=10.0u l=0.28u
XK8_NBNA_0 K8_QNB K8_SETN VSS VSS nfet_03v3 w=2.5u l=0.28u
XK8_NBNB_0 K8_QNB K8_QN VSS VSS nfet_03v3 w=2.5u l=0.28u
XK8_NBPA_0 K8_NB_m K8_SETN VDD VDD pfet_03v3 w=10.0u l=0.28u
XK8_NBPB_0 K8_QNB K8_QN K8_NB_m VDD pfet_03v3 w=10.0u l=0.28u
XK8_DNA_0 D8 K8_QPB K8_D_m VSS nfet_03v3 w=5.0u l=0.28u
XK8_DNB_0 K8_D_m K8_QNB VSS VSS nfet_03v3 w=5.0u l=0.28u
XK8_DPA_0 D8 K8_QPB VDD VDD pfet_03v3 w=5.0u l=0.28u
XK8_DPB_0 D8 K8_QNB VDD VDD pfet_03v3 w=5.0u l=0.28u
XDGP0N_0 GP0 K8_QPB VSS VSS nfet_03v3 w=2.5u l=0.28u
XDGP0P_0 GP0 K8_QPB VDD VDD pfet_03v3 w=5.0u l=0.28u
XDRP0N_0 RP0 K8_QP VSS VSS nfet_03v3 w=2.5u l=0.28u
XDRP0P_0 RP0 K8_QP VDD VDD pfet_03v3 w=5.0u l=0.28u
XDGN0N_0 GN0 K8_QNB VSS VSS nfet_03v3 w=2.5u l=0.28u
XDGN0P_0 GN0 K8_QNB VDD VDD pfet_03v3 w=5.0u l=0.28u
XDRN0N_0 RN0 K8_QN VSS VSS nfet_03v3 w=2.5u l=0.28u
XDRN0P_0 RN0 K8_QN VDD VDD pfet_03v3 w=5.0u l=0.28u
XK9_SNA_0 K9_SAB D8 K9_S_m VSS nfet_03v3 w=5.0u l=0.28u
XK9_SNB_0 K9_S_m VALIDB VSS VSS nfet_03v3 w=5.0u l=0.28u
XK9_SPA_0 K9_SAB D8 VDD VDD pfet_03v3 w=5.0u l=0.28u
XK9_SPB_0 K9_SAB VALIDB VDD VDD pfet_03v3 w=5.0u l=0.28u
XK9_LANA_0 K9_A K9_SAB K9_LA_m VSS nfet_03v3 w=5.0u l=0.28u
XK9_LANB_0 K9_LA_m K9_AB VSS VSS nfet_03v3 w=5.0u l=0.28u
XK9_LAPA_0 K9_A K9_SAB VDD VDD pfet_03v3 w=5.0u l=0.28u
XK9_LAPB_0 K9_A K9_AB VDD VDD pfet_03v3 w=5.0u l=0.28u
XK9_LBNA_0 K9_AB K9_A K9_LB_m VSS nfet_03v3 w=5.0u l=0.28u
XK9_LBNB_0 K9_LB_m RB VSS VSS nfet_03v3 w=5.0u l=0.28u
XK9_LBPA_0 K9_AB K9_A VDD VDD pfet_03v3 w=5.0u l=0.28u
XK9_LBPB_0 K9_AB RB VDD VDD pfet_03v3 w=5.0u l=0.28u
XK9_SPNA_0 K9_SETP K9_AB VSS VSS nfet_03v3 w=2.5u l=0.28u
XK9_SPNB_0 K9_SETP D9 VSS VSS nfet_03v3 w=2.5u l=0.28u
XK9_SPNC_0 K9_SETP DPB VSS VSS nfet_03v3 w=2.5u l=0.28u
XK9_SPPA_0 K9_SP_m1 K9_AB VDD VDD pfet_03v3 w=15.0u l=0.28u
XK9_SPPB_0 K9_SP_m2 D9 K9_SP_m1 VDD pfet_03v3 w=15.0u l=0.28u
XK9_SPPC_0 K9_SETP DPB K9_SP_m2 VDD pfet_03v3 w=15.0u l=0.28u
XK9_SNNA_0 K9_SETN K9_AB VSS VSS nfet_03v3 w=2.5u l=0.28u
XK9_SNNB_0 K9_SETN D9 VSS VSS nfet_03v3 w=2.5u l=0.28u
XK9_SNNC_0 K9_SETN DNB VSS VSS nfet_03v3 w=2.5u l=0.28u
XK9_SNPA_0 K9_SN_m1 K9_AB VDD VDD pfet_03v3 w=15.0u l=0.28u
XK9_SNPB_0 K9_SN_m2 D9 K9_SN_m1 VDD pfet_03v3 w=15.0u l=0.28u
XK9_SNPC_0 K9_SETN DNB K9_SN_m2 VDD pfet_03v3 w=15.0u l=0.28u
XK9_PANA_0 K9_QP R VSS VSS nfet_03v3 w=2.5u l=0.28u
XK9_PANB_0 K9_QP K9_QPB VSS VSS nfet_03v3 w=2.5u l=0.28u
XK9_PAPA_0 K9_PA_m R VDD VDD pfet_03v3 w=10.0u l=0.28u
XK9_PAPB_0 K9_QP K9_QPB K9_PA_m VDD pfet_03v3 w=10.0u l=0.28u
XK9_PBNA_0 K9_QPB K9_SETP VSS VSS nfet_03v3 w=2.5u l=0.28u
XK9_PBNB_0 K9_QPB K9_QP VSS VSS nfet_03v3 w=2.5u l=0.28u
XK9_PBPA_0 K9_PB_m K9_SETP VDD VDD pfet_03v3 w=10.0u l=0.28u
XK9_PBPB_0 K9_QPB K9_QP K9_PB_m VDD pfet_03v3 w=10.0u l=0.28u
XK9_NANA_0 K9_QN R VSS VSS nfet_03v3 w=2.5u l=0.28u
XK9_NANB_0 K9_QN K9_QNB VSS VSS nfet_03v3 w=2.5u l=0.28u
XK9_NAPA_0 K9_NA_m R VDD VDD pfet_03v3 w=10.0u l=0.28u
XK9_NAPB_0 K9_QN K9_QNB K9_NA_m VDD pfet_03v3 w=10.0u l=0.28u
XK9_NBNA_0 K9_QNB K9_SETN VSS VSS nfet_03v3 w=2.5u l=0.28u
XK9_NBNB_0 K9_QNB K9_QN VSS VSS nfet_03v3 w=2.5u l=0.28u
XK9_NBPA_0 K9_NB_m K9_SETN VDD VDD pfet_03v3 w=10.0u l=0.28u
XK9_NBPB_0 K9_QNB K9_QN K9_NB_m VDD pfet_03v3 w=10.0u l=0.28u
XK9_DNA_0 D9 K9_QPB K9_D_m VSS nfet_03v3 w=5.0u l=0.28u
XK9_DNB_0 K9_D_m K9_QNB VSS VSS nfet_03v3 w=5.0u l=0.28u
XK9_DPA_0 D9 K9_QPB VDD VDD pfet_03v3 w=5.0u l=0.28u
XK9_DPB_0 D9 K9_QNB VDD VDD pfet_03v3 w=5.0u l=0.28u
XXL D9 DONE EN OVERLOAD VDD VSS K0_QP K1_QP K2_QP K3_QP K4_QP K5_QP K6_QP K7_QP K8_QP K9_QP CODE0 CODE1 CODE2 CODE3 CODE4 CODE5 CODE6 CODE7 CODE8 CODE9 adc_code_reg
.ends
