* pt_adc_q: transistor-level schematic of converter block adc_q (gf180mcuD).
* Generated by analog/converters/flow.py from circuits.py; do not edit.
* Standard cells: include /pdk/gf180mcuD/libs.ref/gf180mcu_fd_sc_mcu7t5v0/spice/gf180mcu_fd_sc_mcu7t5v0.spice
* v3: 2-way time-interleaved v2 cores; ILEN=0 = single core A (v2 behaviour)
* AP4: 0.3 um track/trunk spacing, >15 um PMOS as 2 fingers, trunk bank ordered for isolation
.subckt adc_code_reg done done_o en overload VDD VSS bp[0] bp[1] bp[2] bp[3] bp[4] bp[5] bp[6] bp[7] bp[8] bp[9] code_tc[0] code_tc[1] code_tc[2] code_tc[3] code_tc[4] code_tc[5] code_tc[6] code_tc[7] code_tc[8] code_tc[9]
XFILLER_0_104 VDD VDD VSS VSS gf180mcu_fd_sc_mcu7t5v0__fillcap_32
XFILLER_0_138 VDD VDD VSS VSS gf180mcu_fd_sc_mcu7t5v0__fillcap_32
XFILLER_0_172 VDD VDD VSS VSS gf180mcu_fd_sc_mcu7t5v0__fillcap_16
XFILLER_0_2 VDD VDD VSS VSS gf180mcu_fd_sc_mcu7t5v0__fillcap_32
XFILLER_0_36 VDD VDD VSS VSS gf180mcu_fd_sc_mcu7t5v0__fillcap_32
XFILLER_0_70 VDD VDD VSS VSS gf180mcu_fd_sc_mcu7t5v0__fillcap_32
XFILLER_10_104 VDD VDD VSS VSS gf180mcu_fd_sc_mcu7t5v0__fillcap_32
XFILLER_10_138 VDD VDD VSS VSS gf180mcu_fd_sc_mcu7t5v0__fillcap_32
XFILLER_10_172 VDD VDD VSS VSS gf180mcu_fd_sc_mcu7t5v0__fillcap_16
XFILLER_10_2 VDD VDD VSS VSS gf180mcu_fd_sc_mcu7t5v0__fillcap_32
XFILLER_10_36 VDD VDD VSS VSS gf180mcu_fd_sc_mcu7t5v0__fillcap_32
XFILLER_10_70 VDD VDD VSS VSS gf180mcu_fd_sc_mcu7t5v0__fillcap_32
XFILLER_1_120 VDD VDD VSS VSS gf180mcu_fd_sc_mcu7t5v0__fillcap_16
XFILLER_1_136 VDD VDD VSS VSS gf180mcu_fd_sc_mcu7t5v0__fillcap_4
XFILLER_1_142 VDD VDD VSS VSS gf180mcu_fd_sc_mcu7t5v0__fillcap_32
XFILLER_1_174 VDD VDD VSS VSS gf180mcu_fd_sc_mcu7t5v0__fillcap_8
XFILLER_1_18 VDD VDD VSS VSS gf180mcu_fd_sc_mcu7t5v0__fillcap_4
XFILLER_1_182 VDD VDD VSS VSS gf180mcu_fd_sc_mcu7t5v0__fillcap_4
XFILLER_1_186 VDD VDD VSS VSS gf180mcu_fd_sc_mcu7t5v0__fill_2
XFILLER_1_2 VDD VDD VSS VSS gf180mcu_fd_sc_mcu7t5v0__fillcap_16
XFILLER_1_22 VDD VDD VSS VSS gf180mcu_fd_sc_mcu7t5v0__fill_2
XFILLER_1_69 VDD VDD VSS VSS gf180mcu_fd_sc_mcu7t5v0__fill_1
XFILLER_1_72 VDD VDD VSS VSS gf180mcu_fd_sc_mcu7t5v0__fillcap_4
XFILLER_1_76 VDD VDD VSS VSS gf180mcu_fd_sc_mcu7t5v0__fill_2
XFILLER_1_88 VDD VDD VSS VSS gf180mcu_fd_sc_mcu7t5v0__fillcap_32
XFILLER_2_103 VDD VDD VSS VSS gf180mcu_fd_sc_mcu7t5v0__fill_2
XFILLER_2_107 VDD VDD VSS VSS gf180mcu_fd_sc_mcu7t5v0__fillcap_64
XFILLER_2_171 VDD VDD VSS VSS gf180mcu_fd_sc_mcu7t5v0__fillcap_4
XFILLER_2_177 VDD VDD VSS VSS gf180mcu_fd_sc_mcu7t5v0__fillcap_8
XFILLER_2_185 VDD VDD VSS VSS gf180mcu_fd_sc_mcu7t5v0__fill_2
XFILLER_2_187 VDD VDD VSS VSS gf180mcu_fd_sc_mcu7t5v0__fill_1
XFILLER_2_2 VDD VDD VSS VSS gf180mcu_fd_sc_mcu7t5v0__fillcap_32
XFILLER_2_34 VDD VDD VSS VSS gf180mcu_fd_sc_mcu7t5v0__fill_1
XFILLER_2_37 VDD VDD VSS VSS gf180mcu_fd_sc_mcu7t5v0__fillcap_16
XFILLER_2_53 VDD VDD VSS VSS gf180mcu_fd_sc_mcu7t5v0__fillcap_8
XFILLER_2_87 VDD VDD VSS VSS gf180mcu_fd_sc_mcu7t5v0__fillcap_16
XFILLER_3_128 VDD VDD VSS VSS gf180mcu_fd_sc_mcu7t5v0__fillcap_8
XFILLER_3_136 VDD VDD VSS VSS gf180mcu_fd_sc_mcu7t5v0__fillcap_4
XFILLER_3_142 VDD VDD VSS VSS gf180mcu_fd_sc_mcu7t5v0__fillcap_32
XFILLER_3_174 VDD VDD VSS VSS gf180mcu_fd_sc_mcu7t5v0__fillcap_8
XFILLER_3_18 VDD VDD VSS VSS gf180mcu_fd_sc_mcu7t5v0__fillcap_4
XFILLER_3_182 VDD VDD VSS VSS gf180mcu_fd_sc_mcu7t5v0__fillcap_4
XFILLER_3_186 VDD VDD VSS VSS gf180mcu_fd_sc_mcu7t5v0__fill_2
XFILLER_3_2 VDD VDD VSS VSS gf180mcu_fd_sc_mcu7t5v0__fillcap_16
XFILLER_3_22 VDD VDD VSS VSS gf180mcu_fd_sc_mcu7t5v0__fill_2
XFILLER_3_58 VDD VDD VSS VSS gf180mcu_fd_sc_mcu7t5v0__fill_2
XFILLER_3_60 VDD VDD VSS VSS gf180mcu_fd_sc_mcu7t5v0__fill_1
XFILLER_3_72 VDD VDD VSS VSS gf180mcu_fd_sc_mcu7t5v0__fill_1
XFILLER_3_84 VDD VDD VSS VSS gf180mcu_fd_sc_mcu7t5v0__fillcap_8
XFILLER_3_92 VDD VDD VSS VSS gf180mcu_fd_sc_mcu7t5v0__fill_2
XFILLER_4_101 VDD VDD VSS VSS gf180mcu_fd_sc_mcu7t5v0__fillcap_4
XFILLER_4_107 VDD VDD VSS VSS gf180mcu_fd_sc_mcu7t5v0__fillcap_16
XFILLER_4_123 VDD VDD VSS VSS gf180mcu_fd_sc_mcu7t5v0__fill_1
XFILLER_4_158 VDD VDD VSS VSS gf180mcu_fd_sc_mcu7t5v0__fillcap_16
XFILLER_4_174 VDD VDD VSS VSS gf180mcu_fd_sc_mcu7t5v0__fill_1
XFILLER_4_177 VDD VDD VSS VSS gf180mcu_fd_sc_mcu7t5v0__fillcap_8
XFILLER_4_185 VDD VDD VSS VSS gf180mcu_fd_sc_mcu7t5v0__fill_2
XFILLER_4_187 VDD VDD VSS VSS gf180mcu_fd_sc_mcu7t5v0__fill_1
XFILLER_4_2 VDD VDD VSS VSS gf180mcu_fd_sc_mcu7t5v0__fillcap_32
XFILLER_4_34 VDD VDD VSS VSS gf180mcu_fd_sc_mcu7t5v0__fill_1
XFILLER_4_37 VDD VDD VSS VSS gf180mcu_fd_sc_mcu7t5v0__fillcap_16
XFILLER_4_53 VDD VDD VSS VSS gf180mcu_fd_sc_mcu7t5v0__fillcap_4
XFILLER_4_57 VDD VDD VSS VSS gf180mcu_fd_sc_mcu7t5v0__fill_2
XFILLER_4_93 VDD VDD VSS VSS gf180mcu_fd_sc_mcu7t5v0__fillcap_8
XFILLER_5_101 VDD VDD VSS VSS gf180mcu_fd_sc_mcu7t5v0__fillcap_32
XFILLER_5_133 VDD VDD VSS VSS gf180mcu_fd_sc_mcu7t5v0__fillcap_4
XFILLER_5_137 VDD VDD VSS VSS gf180mcu_fd_sc_mcu7t5v0__fill_2
XFILLER_5_139 VDD VDD VSS VSS gf180mcu_fd_sc_mcu7t5v0__fill_1
XFILLER_5_142 VDD VDD VSS VSS gf180mcu_fd_sc_mcu7t5v0__fillcap_32
XFILLER_5_174 VDD VDD VSS VSS gf180mcu_fd_sc_mcu7t5v0__fillcap_8
XFILLER_5_182 VDD VDD VSS VSS gf180mcu_fd_sc_mcu7t5v0__fillcap_4
XFILLER_5_186 VDD VDD VSS VSS gf180mcu_fd_sc_mcu7t5v0__fill_2
XFILLER_5_2 VDD VDD VSS VSS gf180mcu_fd_sc_mcu7t5v0__fillcap_64
XFILLER_5_66 VDD VDD VSS VSS gf180mcu_fd_sc_mcu7t5v0__fillcap_4
XFILLER_5_72 VDD VDD VSS VSS gf180mcu_fd_sc_mcu7t5v0__fillcap_16
XFILLER_5_88 VDD VDD VSS VSS gf180mcu_fd_sc_mcu7t5v0__fillcap_8
XFILLER_5_96 VDD VDD VSS VSS gf180mcu_fd_sc_mcu7t5v0__fill_1
XFILLER_6_102 VDD VDD VSS VSS gf180mcu_fd_sc_mcu7t5v0__fill_2
XFILLER_6_104 VDD VDD VSS VSS gf180mcu_fd_sc_mcu7t5v0__fill_1
XFILLER_6_107 VDD VDD VSS VSS gf180mcu_fd_sc_mcu7t5v0__fillcap_64
XFILLER_6_171 VDD VDD VSS VSS gf180mcu_fd_sc_mcu7t5v0__fillcap_4
XFILLER_6_177 VDD VDD VSS VSS gf180mcu_fd_sc_mcu7t5v0__fillcap_8
XFILLER_6_185 VDD VDD VSS VSS gf180mcu_fd_sc_mcu7t5v0__fill_2
XFILLER_6_187 VDD VDD VSS VSS gf180mcu_fd_sc_mcu7t5v0__fill_1
XFILLER_6_2 VDD VDD VSS VSS gf180mcu_fd_sc_mcu7t5v0__fillcap_32
XFILLER_6_34 VDD VDD VSS VSS gf180mcu_fd_sc_mcu7t5v0__fill_1
XFILLER_6_37 VDD VDD VSS VSS gf180mcu_fd_sc_mcu7t5v0__fillcap_8
XFILLER_6_45 VDD VDD VSS VSS gf180mcu_fd_sc_mcu7t5v0__fill_2
XFILLER_6_47 VDD VDD VSS VSS gf180mcu_fd_sc_mcu7t5v0__fill_1
XFILLER_6_82 VDD VDD VSS VSS gf180mcu_fd_sc_mcu7t5v0__fillcap_16
XFILLER_6_98 VDD VDD VSS VSS gf180mcu_fd_sc_mcu7t5v0__fillcap_4
XFILLER_7_104 VDD VDD VSS VSS gf180mcu_fd_sc_mcu7t5v0__fill_2
XFILLER_7_142 VDD VDD VSS VSS gf180mcu_fd_sc_mcu7t5v0__fillcap_32
XFILLER_7_174 VDD VDD VSS VSS gf180mcu_fd_sc_mcu7t5v0__fillcap_8
XFILLER_7_18 VDD VDD VSS VSS gf180mcu_fd_sc_mcu7t5v0__fillcap_8
XFILLER_7_182 VDD VDD VSS VSS gf180mcu_fd_sc_mcu7t5v0__fillcap_4
XFILLER_7_186 VDD VDD VSS VSS gf180mcu_fd_sc_mcu7t5v0__fill_2
XFILLER_7_2 VDD VDD VSS VSS gf180mcu_fd_sc_mcu7t5v0__fillcap_16
XFILLER_7_26 VDD VDD VSS VSS gf180mcu_fd_sc_mcu7t5v0__fillcap_4
XFILLER_7_30 VDD VDD VSS VSS gf180mcu_fd_sc_mcu7t5v0__fill_1
XFILLER_7_65 VDD VDD VSS VSS gf180mcu_fd_sc_mcu7t5v0__fillcap_4
XFILLER_7_69 VDD VDD VSS VSS gf180mcu_fd_sc_mcu7t5v0__fill_1
XFILLER_7_72 VDD VDD VSS VSS gf180mcu_fd_sc_mcu7t5v0__fillcap_32
XFILLER_8_103 VDD VDD VSS VSS gf180mcu_fd_sc_mcu7t5v0__fill_2
XFILLER_8_107 VDD VDD VSS VSS gf180mcu_fd_sc_mcu7t5v0__fillcap_32
XFILLER_8_139 VDD VDD VSS VSS gf180mcu_fd_sc_mcu7t5v0__fillcap_16
XFILLER_8_155 VDD VDD VSS VSS gf180mcu_fd_sc_mcu7t5v0__fillcap_8
XFILLER_8_163 VDD VDD VSS VSS gf180mcu_fd_sc_mcu7t5v0__fillcap_4
XFILLER_8_177 VDD VDD VSS VSS gf180mcu_fd_sc_mcu7t5v0__fillcap_8
XFILLER_8_185 VDD VDD VSS VSS gf180mcu_fd_sc_mcu7t5v0__fill_2
XFILLER_8_187 VDD VDD VSS VSS gf180mcu_fd_sc_mcu7t5v0__fill_1
XFILLER_8_2 VDD VDD VSS VSS gf180mcu_fd_sc_mcu7t5v0__fillcap_32
XFILLER_8_34 VDD VDD VSS VSS gf180mcu_fd_sc_mcu7t5v0__fill_1
XFILLER_8_37 VDD VDD VSS VSS gf180mcu_fd_sc_mcu7t5v0__fillcap_32
XFILLER_9_114 VDD VDD VSS VSS gf180mcu_fd_sc_mcu7t5v0__fillcap_16
XFILLER_9_130 VDD VDD VSS VSS gf180mcu_fd_sc_mcu7t5v0__fillcap_8
XFILLER_9_138 VDD VDD VSS VSS gf180mcu_fd_sc_mcu7t5v0__fill_2
XFILLER_9_142 VDD VDD VSS VSS gf180mcu_fd_sc_mcu7t5v0__fillcap_32
XFILLER_9_174 VDD VDD VSS VSS gf180mcu_fd_sc_mcu7t5v0__fillcap_8
XFILLER_9_18 VDD VDD VSS VSS gf180mcu_fd_sc_mcu7t5v0__fillcap_8
XFILLER_9_182 VDD VDD VSS VSS gf180mcu_fd_sc_mcu7t5v0__fillcap_4
XFILLER_9_186 VDD VDD VSS VSS gf180mcu_fd_sc_mcu7t5v0__fill_2
XFILLER_9_2 VDD VDD VSS VSS gf180mcu_fd_sc_mcu7t5v0__fillcap_16
XFILLER_9_26 VDD VDD VSS VSS gf180mcu_fd_sc_mcu7t5v0__fill_1
XFILLER_9_61 VDD VDD VSS VSS gf180mcu_fd_sc_mcu7t5v0__fillcap_8
XFILLER_9_69 VDD VDD VSS VSS gf180mcu_fd_sc_mcu7t5v0__fill_1
XFILLER_9_72 VDD VDD VSS VSS gf180mcu_fd_sc_mcu7t5v0__fillcap_8
XPHY_EDGE_ROW_0_Left_11 VDD VDD VSS VSS gf180mcu_fd_sc_mcu7t5v0__endcap
XPHY_EDGE_ROW_0_Right_0 VDD VDD VSS VSS gf180mcu_fd_sc_mcu7t5v0__endcap
XPHY_EDGE_ROW_10_Left_21 VDD VDD VSS VSS gf180mcu_fd_sc_mcu7t5v0__endcap
XPHY_EDGE_ROW_10_Right_10 VDD VDD VSS VSS gf180mcu_fd_sc_mcu7t5v0__endcap
XPHY_EDGE_ROW_1_Left_12 VDD VDD VSS VSS gf180mcu_fd_sc_mcu7t5v0__endcap
XPHY_EDGE_ROW_1_Right_1 VDD VDD VSS VSS gf180mcu_fd_sc_mcu7t5v0__endcap
XPHY_EDGE_ROW_2_Left_13 VDD VDD VSS VSS gf180mcu_fd_sc_mcu7t5v0__endcap
XPHY_EDGE_ROW_2_Right_2 VDD VDD VSS VSS gf180mcu_fd_sc_mcu7t5v0__endcap
XPHY_EDGE_ROW_3_Left_14 VDD VDD VSS VSS gf180mcu_fd_sc_mcu7t5v0__endcap
XPHY_EDGE_ROW_3_Right_3 VDD VDD VSS VSS gf180mcu_fd_sc_mcu7t5v0__endcap
XPHY_EDGE_ROW_4_Left_15 VDD VDD VSS VSS gf180mcu_fd_sc_mcu7t5v0__endcap
XPHY_EDGE_ROW_4_Right_4 VDD VDD VSS VSS gf180mcu_fd_sc_mcu7t5v0__endcap
XPHY_EDGE_ROW_5_Left_16 VDD VDD VSS VSS gf180mcu_fd_sc_mcu7t5v0__endcap
XPHY_EDGE_ROW_5_Right_5 VDD VDD VSS VSS gf180mcu_fd_sc_mcu7t5v0__endcap
XPHY_EDGE_ROW_6_Left_17 VDD VDD VSS VSS gf180mcu_fd_sc_mcu7t5v0__endcap
XPHY_EDGE_ROW_6_Right_6 VDD VDD VSS VSS gf180mcu_fd_sc_mcu7t5v0__endcap
XPHY_EDGE_ROW_7_Left_18 VDD VDD VSS VSS gf180mcu_fd_sc_mcu7t5v0__endcap
XPHY_EDGE_ROW_7_Right_7 VDD VDD VSS VSS gf180mcu_fd_sc_mcu7t5v0__endcap
XPHY_EDGE_ROW_8_Left_19 VDD VDD VSS VSS gf180mcu_fd_sc_mcu7t5v0__endcap
XPHY_EDGE_ROW_8_Right_8 VDD VDD VSS VSS gf180mcu_fd_sc_mcu7t5v0__endcap
XPHY_EDGE_ROW_9_Left_20 VDD VDD VSS VSS gf180mcu_fd_sc_mcu7t5v0__endcap
XPHY_EDGE_ROW_9_Right_9 VDD VDD VSS VSS gf180mcu_fd_sc_mcu7t5v0__endcap
XTAP_TAPCELL_ROW_0_22 VDD VSS gf180mcu_fd_sc_mcu7t5v0__filltie
XTAP_TAPCELL_ROW_0_23 VDD VSS gf180mcu_fd_sc_mcu7t5v0__filltie
XTAP_TAPCELL_ROW_0_24 VDD VSS gf180mcu_fd_sc_mcu7t5v0__filltie
XTAP_TAPCELL_ROW_0_25 VDD VSS gf180mcu_fd_sc_mcu7t5v0__filltie
XTAP_TAPCELL_ROW_0_26 VDD VSS gf180mcu_fd_sc_mcu7t5v0__filltie
XTAP_TAPCELL_ROW_10_49 VDD VSS gf180mcu_fd_sc_mcu7t5v0__filltie
XTAP_TAPCELL_ROW_10_50 VDD VSS gf180mcu_fd_sc_mcu7t5v0__filltie
XTAP_TAPCELL_ROW_10_51 VDD VSS gf180mcu_fd_sc_mcu7t5v0__filltie
XTAP_TAPCELL_ROW_10_52 VDD VSS gf180mcu_fd_sc_mcu7t5v0__filltie
XTAP_TAPCELL_ROW_10_53 VDD VSS gf180mcu_fd_sc_mcu7t5v0__filltie
XTAP_TAPCELL_ROW_1_27 VDD VSS gf180mcu_fd_sc_mcu7t5v0__filltie
XTAP_TAPCELL_ROW_1_28 VDD VSS gf180mcu_fd_sc_mcu7t5v0__filltie
XTAP_TAPCELL_ROW_2_29 VDD VSS gf180mcu_fd_sc_mcu7t5v0__filltie
XTAP_TAPCELL_ROW_2_30 VDD VSS gf180mcu_fd_sc_mcu7t5v0__filltie
XTAP_TAPCELL_ROW_2_31 VDD VSS gf180mcu_fd_sc_mcu7t5v0__filltie
XTAP_TAPCELL_ROW_3_32 VDD VSS gf180mcu_fd_sc_mcu7t5v0__filltie
XTAP_TAPCELL_ROW_3_33 VDD VSS gf180mcu_fd_sc_mcu7t5v0__filltie
XTAP_TAPCELL_ROW_4_34 VDD VSS gf180mcu_fd_sc_mcu7t5v0__filltie
XTAP_TAPCELL_ROW_4_35 VDD VSS gf180mcu_fd_sc_mcu7t5v0__filltie
XTAP_TAPCELL_ROW_4_36 VDD VSS gf180mcu_fd_sc_mcu7t5v0__filltie
XTAP_TAPCELL_ROW_5_37 VDD VSS gf180mcu_fd_sc_mcu7t5v0__filltie
XTAP_TAPCELL_ROW_5_38 VDD VSS gf180mcu_fd_sc_mcu7t5v0__filltie
XTAP_TAPCELL_ROW_6_39 VDD VSS gf180mcu_fd_sc_mcu7t5v0__filltie
XTAP_TAPCELL_ROW_6_40 VDD VSS gf180mcu_fd_sc_mcu7t5v0__filltie
XTAP_TAPCELL_ROW_6_41 VDD VSS gf180mcu_fd_sc_mcu7t5v0__filltie
XTAP_TAPCELL_ROW_7_42 VDD VSS gf180mcu_fd_sc_mcu7t5v0__filltie
XTAP_TAPCELL_ROW_7_43 VDD VSS gf180mcu_fd_sc_mcu7t5v0__filltie
XTAP_TAPCELL_ROW_8_44 VDD VSS gf180mcu_fd_sc_mcu7t5v0__filltie
XTAP_TAPCELL_ROW_8_45 VDD VSS gf180mcu_fd_sc_mcu7t5v0__filltie
XTAP_TAPCELL_ROW_8_46 VDD VSS gf180mcu_fd_sc_mcu7t5v0__filltie
XTAP_TAPCELL_ROW_9_47 VDD VSS gf180mcu_fd_sc_mcu7t5v0__filltie
XTAP_TAPCELL_ROW_9_48 VDD VSS gf180mcu_fd_sc_mcu7t5v0__filltie
X_08_ bp[0] _00_ VDD VDD VSS VSS gf180mcu_fd_sc_mcu7t5v0__clkinv_1
X_09_ bp[9] bp[8] bp[1] bp[0] _02_ VDD VDD VSS VSS gf180mcu_fd_sc_mcu7t5v0__and4_1
X_10_ bp[5] bp[4] bp[7] bp[6] _03_ VDD VDD VSS VSS gf180mcu_fd_sc_mcu7t5v0__and4_1
X_11_ bp[3] bp[2] _02_ _03_ _04_ VDD VDD VSS VSS gf180mcu_fd_sc_mcu7t5v0__nand4_1
X_12_ bp[9] bp[8] bp[1] bp[0] _05_ VDD VDD VSS VSS gf180mcu_fd_sc_mcu7t5v0__nor4_1
X_13_ bp[5] bp[4] bp[7] bp[6] _06_ VDD VDD VSS VSS gf180mcu_fd_sc_mcu7t5v0__nor4_1
X_14_ _05_ _06_ _07_ VDD VDD VSS VSS gf180mcu_fd_sc_mcu7t5v0__nand2_1
X_15_ bp[3] bp[2] _07_ _04_ _01_ VDD VDD VSS VSS gf180mcu_fd_sc_mcu7t5v0__oai31_1
X_16_ en done done_o VDD VDD VSS VSS gf180mcu_fd_sc_mcu7t5v0__and2_1
X_17_ bp[9] en done code_tc[0] VDD VDD VSS VSS gf180mcu_fd_sc_mcu7t5v0__dffrnq_1
X_18_ bp[8] en done code_tc[1] VDD VDD VSS VSS gf180mcu_fd_sc_mcu7t5v0__dffrnq_1
X_19_ bp[7] en done code_tc[2] VDD VDD VSS VSS gf180mcu_fd_sc_mcu7t5v0__dffrnq_1
X_20_ bp[6] en done code_tc[3] VDD VDD VSS VSS gf180mcu_fd_sc_mcu7t5v0__dffrnq_1
X_21_ bp[5] en done code_tc[4] VDD VDD VSS VSS gf180mcu_fd_sc_mcu7t5v0__dffrnq_1
X_22_ bp[4] en done code_tc[5] VDD VDD VSS VSS gf180mcu_fd_sc_mcu7t5v0__dffrnq_1
X_23_ bp[3] en done code_tc[6] VDD VDD VSS VSS gf180mcu_fd_sc_mcu7t5v0__dffrnq_1
X_24_ bp[2] en done code_tc[7] VDD VDD VSS VSS gf180mcu_fd_sc_mcu7t5v0__dffrnq_1
X_25_ bp[1] en done code_tc[8] VDD VDD VSS VSS gf180mcu_fd_sc_mcu7t5v0__dffrnq_1
X_26_ _00_ en done code_tc[9] VDD VDD VSS VSS gf180mcu_fd_sc_mcu7t5v0__dffrnq_1
X_27_ _01_ en done overload VDD VDD VSS VSS gf180mcu_fd_sc_mcu7t5v0__dffrnq_1
.ends

.subckt adc_code_reg done done_o en overload VDD VSS bp[0] bp[1] bp[2] bp[3] bp[4] bp[5] bp[6] bp[7] bp[8] bp[9] code_tc[0] code_tc[1] code_tc[2] code_tc[3] code_tc[4] code_tc[5] code_tc[6] code_tc[7] code_tc[8] code_tc[9]
XFILLER_0_104 VDD VDD VSS VSS gf180mcu_fd_sc_mcu7t5v0__fillcap_32
XFILLER_0_138 VDD VDD VSS VSS gf180mcu_fd_sc_mcu7t5v0__fillcap_32
XFILLER_0_172 VDD VDD VSS VSS gf180mcu_fd_sc_mcu7t5v0__fillcap_16
XFILLER_0_2 VDD VDD VSS VSS gf180mcu_fd_sc_mcu7t5v0__fillcap_32
XFILLER_0_36 VDD VDD VSS VSS gf180mcu_fd_sc_mcu7t5v0__fillcap_32
XFILLER_0_70 VDD VDD VSS VSS gf180mcu_fd_sc_mcu7t5v0__fillcap_32
XFILLER_10_104 VDD VDD VSS VSS gf180mcu_fd_sc_mcu7t5v0__fillcap_32
XFILLER_10_138 VDD VDD VSS VSS gf180mcu_fd_sc_mcu7t5v0__fillcap_32
XFILLER_10_172 VDD VDD VSS VSS gf180mcu_fd_sc_mcu7t5v0__fillcap_16
XFILLER_10_2 VDD VDD VSS VSS gf180mcu_fd_sc_mcu7t5v0__fillcap_32
XFILLER_10_36 VDD VDD VSS VSS gf180mcu_fd_sc_mcu7t5v0__fillcap_32
XFILLER_10_70 VDD VDD VSS VSS gf180mcu_fd_sc_mcu7t5v0__fillcap_32
XFILLER_1_120 VDD VDD VSS VSS gf180mcu_fd_sc_mcu7t5v0__fillcap_16
XFILLER_1_136 VDD VDD VSS VSS gf180mcu_fd_sc_mcu7t5v0__fillcap_4
XFILLER_1_142 VDD VDD VSS VSS gf180mcu_fd_sc_mcu7t5v0__fillcap_32
XFILLER_1_174 VDD VDD VSS VSS gf180mcu_fd_sc_mcu7t5v0__fillcap_8
XFILLER_1_18 VDD VDD VSS VSS gf180mcu_fd_sc_mcu7t5v0__fillcap_4
XFILLER_1_182 VDD VDD VSS VSS gf180mcu_fd_sc_mcu7t5v0__fillcap_4
XFILLER_1_186 VDD VDD VSS VSS gf180mcu_fd_sc_mcu7t5v0__fill_2
XFILLER_1_2 VDD VDD VSS VSS gf180mcu_fd_sc_mcu7t5v0__fillcap_16
XFILLER_1_22 VDD VDD VSS VSS gf180mcu_fd_sc_mcu7t5v0__fill_2
XFILLER_1_69 VDD VDD VSS VSS gf180mcu_fd_sc_mcu7t5v0__fill_1
XFILLER_1_72 VDD VDD VSS VSS gf180mcu_fd_sc_mcu7t5v0__fillcap_4
XFILLER_1_76 VDD VDD VSS VSS gf180mcu_fd_sc_mcu7t5v0__fill_2
XFILLER_1_88 VDD VDD VSS VSS gf180mcu_fd_sc_mcu7t5v0__fillcap_32
XFILLER_2_103 VDD VDD VSS VSS gf180mcu_fd_sc_mcu7t5v0__fill_2
XFILLER_2_107 VDD VDD VSS VSS gf180mcu_fd_sc_mcu7t5v0__fillcap_64
XFILLER_2_171 VDD VDD VSS VSS gf180mcu_fd_sc_mcu7t5v0__fillcap_4
XFILLER_2_177 VDD VDD VSS VSS gf180mcu_fd_sc_mcu7t5v0__fillcap_8
XFILLER_2_185 VDD VDD VSS VSS gf180mcu_fd_sc_mcu7t5v0__fill_2
XFILLER_2_187 VDD VDD VSS VSS gf180mcu_fd_sc_mcu7t5v0__fill_1
XFILLER_2_2 VDD VDD VSS VSS gf180mcu_fd_sc_mcu7t5v0__fillcap_32
XFILLER_2_34 VDD VDD VSS VSS gf180mcu_fd_sc_mcu7t5v0__fill_1
XFILLER_2_37 VDD VDD VSS VSS gf180mcu_fd_sc_mcu7t5v0__fillcap_16
XFILLER_2_53 VDD VDD VSS VSS gf180mcu_fd_sc_mcu7t5v0__fillcap_8
XFILLER_2_87 VDD VDD VSS VSS gf180mcu_fd_sc_mcu7t5v0__fillcap_16
XFILLER_3_128 VDD VDD VSS VSS gf180mcu_fd_sc_mcu7t5v0__fillcap_8
XFILLER_3_136 VDD VDD VSS VSS gf180mcu_fd_sc_mcu7t5v0__fillcap_4
XFILLER_3_142 VDD VDD VSS VSS gf180mcu_fd_sc_mcu7t5v0__fillcap_32
XFILLER_3_174 VDD VDD VSS VSS gf180mcu_fd_sc_mcu7t5v0__fillcap_8
XFILLER_3_18 VDD VDD VSS VSS gf180mcu_fd_sc_mcu7t5v0__fillcap_4
XFILLER_3_182 VDD VDD VSS VSS gf180mcu_fd_sc_mcu7t5v0__fillcap_4
XFILLER_3_186 VDD VDD VSS VSS gf180mcu_fd_sc_mcu7t5v0__fill_2
XFILLER_3_2 VDD VDD VSS VSS gf180mcu_fd_sc_mcu7t5v0__fillcap_16
XFILLER_3_22 VDD VDD VSS VSS gf180mcu_fd_sc_mcu7t5v0__fill_2
XFILLER_3_58 VDD VDD VSS VSS gf180mcu_fd_sc_mcu7t5v0__fill_2
XFILLER_3_60 VDD VDD VSS VSS gf180mcu_fd_sc_mcu7t5v0__fill_1
XFILLER_3_72 VDD VDD VSS VSS gf180mcu_fd_sc_mcu7t5v0__fill_1
XFILLER_3_84 VDD VDD VSS VSS gf180mcu_fd_sc_mcu7t5v0__fillcap_8
XFILLER_3_92 VDD VDD VSS VSS gf180mcu_fd_sc_mcu7t5v0__fill_2
XFILLER_4_101 VDD VDD VSS VSS gf180mcu_fd_sc_mcu7t5v0__fillcap_4
XFILLER_4_107 VDD VDD VSS VSS gf180mcu_fd_sc_mcu7t5v0__fillcap_16
XFILLER_4_123 VDD VDD VSS VSS gf180mcu_fd_sc_mcu7t5v0__fill_1
XFILLER_4_158 VDD VDD VSS VSS gf180mcu_fd_sc_mcu7t5v0__fillcap_16
XFILLER_4_174 VDD VDD VSS VSS gf180mcu_fd_sc_mcu7t5v0__fill_1
XFILLER_4_177 VDD VDD VSS VSS gf180mcu_fd_sc_mcu7t5v0__fillcap_8
XFILLER_4_185 VDD VDD VSS VSS gf180mcu_fd_sc_mcu7t5v0__fill_2
XFILLER_4_187 VDD VDD VSS VSS gf180mcu_fd_sc_mcu7t5v0__fill_1
XFILLER_4_2 VDD VDD VSS VSS gf180mcu_fd_sc_mcu7t5v0__fillcap_32
XFILLER_4_34 VDD VDD VSS VSS gf180mcu_fd_sc_mcu7t5v0__fill_1
XFILLER_4_37 VDD VDD VSS VSS gf180mcu_fd_sc_mcu7t5v0__fillcap_16
XFILLER_4_53 VDD VDD VSS VSS gf180mcu_fd_sc_mcu7t5v0__fillcap_4
XFILLER_4_57 VDD VDD VSS VSS gf180mcu_fd_sc_mcu7t5v0__fill_2
XFILLER_4_93 VDD VDD VSS VSS gf180mcu_fd_sc_mcu7t5v0__fillcap_8
XFILLER_5_101 VDD VDD VSS VSS gf180mcu_fd_sc_mcu7t5v0__fillcap_32
XFILLER_5_133 VDD VDD VSS VSS gf180mcu_fd_sc_mcu7t5v0__fillcap_4
XFILLER_5_137 VDD VDD VSS VSS gf180mcu_fd_sc_mcu7t5v0__fill_2
XFILLER_5_139 VDD VDD VSS VSS gf180mcu_fd_sc_mcu7t5v0__fill_1
XFILLER_5_142 VDD VDD VSS VSS gf180mcu_fd_sc_mcu7t5v0__fillcap_32
XFILLER_5_174 VDD VDD VSS VSS gf180mcu_fd_sc_mcu7t5v0__fillcap_8
XFILLER_5_182 VDD VDD VSS VSS gf180mcu_fd_sc_mcu7t5v0__fillcap_4
XFILLER_5_186 VDD VDD VSS VSS gf180mcu_fd_sc_mcu7t5v0__fill_2
XFILLER_5_2 VDD VDD VSS VSS gf180mcu_fd_sc_mcu7t5v0__fillcap_64
XFILLER_5_66 VDD VDD VSS VSS gf180mcu_fd_sc_mcu7t5v0__fillcap_4
XFILLER_5_72 VDD VDD VSS VSS gf180mcu_fd_sc_mcu7t5v0__fillcap_16
XFILLER_5_88 VDD VDD VSS VSS gf180mcu_fd_sc_mcu7t5v0__fillcap_8
XFILLER_5_96 VDD VDD VSS VSS gf180mcu_fd_sc_mcu7t5v0__fill_1
XFILLER_6_102 VDD VDD VSS VSS gf180mcu_fd_sc_mcu7t5v0__fill_2
XFILLER_6_104 VDD VDD VSS VSS gf180mcu_fd_sc_mcu7t5v0__fill_1
XFILLER_6_107 VDD VDD VSS VSS gf180mcu_fd_sc_mcu7t5v0__fillcap_64
XFILLER_6_171 VDD VDD VSS VSS gf180mcu_fd_sc_mcu7t5v0__fillcap_4
XFILLER_6_177 VDD VDD VSS VSS gf180mcu_fd_sc_mcu7t5v0__fillcap_8
XFILLER_6_185 VDD VDD VSS VSS gf180mcu_fd_sc_mcu7t5v0__fill_2
XFILLER_6_187 VDD VDD VSS VSS gf180mcu_fd_sc_mcu7t5v0__fill_1
XFILLER_6_2 VDD VDD VSS VSS gf180mcu_fd_sc_mcu7t5v0__fillcap_32
XFILLER_6_34 VDD VDD VSS VSS gf180mcu_fd_sc_mcu7t5v0__fill_1
XFILLER_6_37 VDD VDD VSS VSS gf180mcu_fd_sc_mcu7t5v0__fillcap_8
XFILLER_6_45 VDD VDD VSS VSS gf180mcu_fd_sc_mcu7t5v0__fill_2
XFILLER_6_47 VDD VDD VSS VSS gf180mcu_fd_sc_mcu7t5v0__fill_1
XFILLER_6_82 VDD VDD VSS VSS gf180mcu_fd_sc_mcu7t5v0__fillcap_16
XFILLER_6_98 VDD VDD VSS VSS gf180mcu_fd_sc_mcu7t5v0__fillcap_4
XFILLER_7_104 VDD VDD VSS VSS gf180mcu_fd_sc_mcu7t5v0__fill_2
XFILLER_7_142 VDD VDD VSS VSS gf180mcu_fd_sc_mcu7t5v0__fillcap_32
XFILLER_7_174 VDD VDD VSS VSS gf180mcu_fd_sc_mcu7t5v0__fillcap_8
XFILLER_7_18 VDD VDD VSS VSS gf180mcu_fd_sc_mcu7t5v0__fillcap_8
XFILLER_7_182 VDD VDD VSS VSS gf180mcu_fd_sc_mcu7t5v0__fillcap_4
XFILLER_7_186 VDD VDD VSS VSS gf180mcu_fd_sc_mcu7t5v0__fill_2
XFILLER_7_2 VDD VDD VSS VSS gf180mcu_fd_sc_mcu7t5v0__fillcap_16
XFILLER_7_26 VDD VDD VSS VSS gf180mcu_fd_sc_mcu7t5v0__fillcap_4
XFILLER_7_30 VDD VDD VSS VSS gf180mcu_fd_sc_mcu7t5v0__fill_1
XFILLER_7_65 VDD VDD VSS VSS gf180mcu_fd_sc_mcu7t5v0__fillcap_4
XFILLER_7_69 VDD VDD VSS VSS gf180mcu_fd_sc_mcu7t5v0__fill_1
XFILLER_7_72 VDD VDD VSS VSS gf180mcu_fd_sc_mcu7t5v0__fillcap_32
XFILLER_8_103 VDD VDD VSS VSS gf180mcu_fd_sc_mcu7t5v0__fill_2
XFILLER_8_107 VDD VDD VSS VSS gf180mcu_fd_sc_mcu7t5v0__fillcap_32
XFILLER_8_139 VDD VDD VSS VSS gf180mcu_fd_sc_mcu7t5v0__fillcap_16
XFILLER_8_155 VDD VDD VSS VSS gf180mcu_fd_sc_mcu7t5v0__fillcap_8
XFILLER_8_163 VDD VDD VSS VSS gf180mcu_fd_sc_mcu7t5v0__fillcap_4
XFILLER_8_177 VDD VDD VSS VSS gf180mcu_fd_sc_mcu7t5v0__fillcap_8
XFILLER_8_185 VDD VDD VSS VSS gf180mcu_fd_sc_mcu7t5v0__fill_2
XFILLER_8_187 VDD VDD VSS VSS gf180mcu_fd_sc_mcu7t5v0__fill_1
XFILLER_8_2 VDD VDD VSS VSS gf180mcu_fd_sc_mcu7t5v0__fillcap_32
XFILLER_8_34 VDD VDD VSS VSS gf180mcu_fd_sc_mcu7t5v0__fill_1
XFILLER_8_37 VDD VDD VSS VSS gf180mcu_fd_sc_mcu7t5v0__fillcap_32
XFILLER_9_114 VDD VDD VSS VSS gf180mcu_fd_sc_mcu7t5v0__fillcap_16
XFILLER_9_130 VDD VDD VSS VSS gf180mcu_fd_sc_mcu7t5v0__fillcap_8
XFILLER_9_138 VDD VDD VSS VSS gf180mcu_fd_sc_mcu7t5v0__fill_2
XFILLER_9_142 VDD VDD VSS VSS gf180mcu_fd_sc_mcu7t5v0__fillcap_32
XFILLER_9_174 VDD VDD VSS VSS gf180mcu_fd_sc_mcu7t5v0__fillcap_8
XFILLER_9_18 VDD VDD VSS VSS gf180mcu_fd_sc_mcu7t5v0__fillcap_8
XFILLER_9_182 VDD VDD VSS VSS gf180mcu_fd_sc_mcu7t5v0__fillcap_4
XFILLER_9_186 VDD VDD VSS VSS gf180mcu_fd_sc_mcu7t5v0__fill_2
XFILLER_9_2 VDD VDD VSS VSS gf180mcu_fd_sc_mcu7t5v0__fillcap_16
XFILLER_9_26 VDD VDD VSS VSS gf180mcu_fd_sc_mcu7t5v0__fill_1
XFILLER_9_61 VDD VDD VSS VSS gf180mcu_fd_sc_mcu7t5v0__fillcap_8
XFILLER_9_69 VDD VDD VSS VSS gf180mcu_fd_sc_mcu7t5v0__fill_1
XFILLER_9_72 VDD VDD VSS VSS gf180mcu_fd_sc_mcu7t5v0__fillcap_8
XPHY_EDGE_ROW_0_Left_11 VDD VDD VSS VSS gf180mcu_fd_sc_mcu7t5v0__endcap
XPHY_EDGE_ROW_0_Right_0 VDD VDD VSS VSS gf180mcu_fd_sc_mcu7t5v0__endcap
XPHY_EDGE_ROW_10_Left_21 VDD VDD VSS VSS gf180mcu_fd_sc_mcu7t5v0__endcap
XPHY_EDGE_ROW_10_Right_10 VDD VDD VSS VSS gf180mcu_fd_sc_mcu7t5v0__endcap
XPHY_EDGE_ROW_1_Left_12 VDD VDD VSS VSS gf180mcu_fd_sc_mcu7t5v0__endcap
XPHY_EDGE_ROW_1_Right_1 VDD VDD VSS VSS gf180mcu_fd_sc_mcu7t5v0__endcap
XPHY_EDGE_ROW_2_Left_13 VDD VDD VSS VSS gf180mcu_fd_sc_mcu7t5v0__endcap
XPHY_EDGE_ROW_2_Right_2 VDD VDD VSS VSS gf180mcu_fd_sc_mcu7t5v0__endcap
XPHY_EDGE_ROW_3_Left_14 VDD VDD VSS VSS gf180mcu_fd_sc_mcu7t5v0__endcap
XPHY_EDGE_ROW_3_Right_3 VDD VDD VSS VSS gf180mcu_fd_sc_mcu7t5v0__endcap
XPHY_EDGE_ROW_4_Left_15 VDD VDD VSS VSS gf180mcu_fd_sc_mcu7t5v0__endcap
XPHY_EDGE_ROW_4_Right_4 VDD VDD VSS VSS gf180mcu_fd_sc_mcu7t5v0__endcap
XPHY_EDGE_ROW_5_Left_16 VDD VDD VSS VSS gf180mcu_fd_sc_mcu7t5v0__endcap
XPHY_EDGE_ROW_5_Right_5 VDD VDD VSS VSS gf180mcu_fd_sc_mcu7t5v0__endcap
XPHY_EDGE_ROW_6_Left_17 VDD VDD VSS VSS gf180mcu_fd_sc_mcu7t5v0__endcap
XPHY_EDGE_ROW_6_Right_6 VDD VDD VSS VSS gf180mcu_fd_sc_mcu7t5v0__endcap
XPHY_EDGE_ROW_7_Left_18 VDD VDD VSS VSS gf180mcu_fd_sc_mcu7t5v0__endcap
XPHY_EDGE_ROW_7_Right_7 VDD VDD VSS VSS gf180mcu_fd_sc_mcu7t5v0__endcap
XPHY_EDGE_ROW_8_Left_19 VDD VDD VSS VSS gf180mcu_fd_sc_mcu7t5v0__endcap
XPHY_EDGE_ROW_8_Right_8 VDD VDD VSS VSS gf180mcu_fd_sc_mcu7t5v0__endcap
XPHY_EDGE_ROW_9_Left_20 VDD VDD VSS VSS gf180mcu_fd_sc_mcu7t5v0__endcap
XPHY_EDGE_ROW_9_Right_9 VDD VDD VSS VSS gf180mcu_fd_sc_mcu7t5v0__endcap
XTAP_TAPCELL_ROW_0_22 VDD VSS gf180mcu_fd_sc_mcu7t5v0__filltie
XTAP_TAPCELL_ROW_0_23 VDD VSS gf180mcu_fd_sc_mcu7t5v0__filltie
XTAP_TAPCELL_ROW_0_24 VDD VSS gf180mcu_fd_sc_mcu7t5v0__filltie
XTAP_TAPCELL_ROW_0_25 VDD VSS gf180mcu_fd_sc_mcu7t5v0__filltie
XTAP_TAPCELL_ROW_0_26 VDD VSS gf180mcu_fd_sc_mcu7t5v0__filltie
XTAP_TAPCELL_ROW_10_49 VDD VSS gf180mcu_fd_sc_mcu7t5v0__filltie
XTAP_TAPCELL_ROW_10_50 VDD VSS gf180mcu_fd_sc_mcu7t5v0__filltie
XTAP_TAPCELL_ROW_10_51 VDD VSS gf180mcu_fd_sc_mcu7t5v0__filltie
XTAP_TAPCELL_ROW_10_52 VDD VSS gf180mcu_fd_sc_mcu7t5v0__filltie
XTAP_TAPCELL_ROW_10_53 VDD VSS gf180mcu_fd_sc_mcu7t5v0__filltie
XTAP_TAPCELL_ROW_1_27 VDD VSS gf180mcu_fd_sc_mcu7t5v0__filltie
XTAP_TAPCELL_ROW_1_28 VDD VSS gf180mcu_fd_sc_mcu7t5v0__filltie
XTAP_TAPCELL_ROW_2_29 VDD VSS gf180mcu_fd_sc_mcu7t5v0__filltie
XTAP_TAPCELL_ROW_2_30 VDD VSS gf180mcu_fd_sc_mcu7t5v0__filltie
XTAP_TAPCELL_ROW_2_31 VDD VSS gf180mcu_fd_sc_mcu7t5v0__filltie
XTAP_TAPCELL_ROW_3_32 VDD VSS gf180mcu_fd_sc_mcu7t5v0__filltie
XTAP_TAPCELL_ROW_3_33 VDD VSS gf180mcu_fd_sc_mcu7t5v0__filltie
XTAP_TAPCELL_ROW_4_34 VDD VSS gf180mcu_fd_sc_mcu7t5v0__filltie
XTAP_TAPCELL_ROW_4_35 VDD VSS gf180mcu_fd_sc_mcu7t5v0__filltie
XTAP_TAPCELL_ROW_4_36 VDD VSS gf180mcu_fd_sc_mcu7t5v0__filltie
XTAP_TAPCELL_ROW_5_37 VDD VSS gf180mcu_fd_sc_mcu7t5v0__filltie
XTAP_TAPCELL_ROW_5_38 VDD VSS gf180mcu_fd_sc_mcu7t5v0__filltie
XTAP_TAPCELL_ROW_6_39 VDD VSS gf180mcu_fd_sc_mcu7t5v0__filltie
XTAP_TAPCELL_ROW_6_40 VDD VSS gf180mcu_fd_sc_mcu7t5v0__filltie
XTAP_TAPCELL_ROW_6_41 VDD VSS gf180mcu_fd_sc_mcu7t5v0__filltie
XTAP_TAPCELL_ROW_7_42 VDD VSS gf180mcu_fd_sc_mcu7t5v0__filltie
XTAP_TAPCELL_ROW_7_43 VDD VSS gf180mcu_fd_sc_mcu7t5v0__filltie
XTAP_TAPCELL_ROW_8_44 VDD VSS gf180mcu_fd_sc_mcu7t5v0__filltie
XTAP_TAPCELL_ROW_8_45 VDD VSS gf180mcu_fd_sc_mcu7t5v0__filltie
XTAP_TAPCELL_ROW_8_46 VDD VSS gf180mcu_fd_sc_mcu7t5v0__filltie
XTAP_TAPCELL_ROW_9_47 VDD VSS gf180mcu_fd_sc_mcu7t5v0__filltie
XTAP_TAPCELL_ROW_9_48 VDD VSS gf180mcu_fd_sc_mcu7t5v0__filltie
X_08_ bp[0] _00_ VDD VDD VSS VSS gf180mcu_fd_sc_mcu7t5v0__clkinv_1
X_09_ bp[9] bp[8] bp[1] bp[0] _02_ VDD VDD VSS VSS gf180mcu_fd_sc_mcu7t5v0__and4_1
X_10_ bp[5] bp[4] bp[7] bp[6] _03_ VDD VDD VSS VSS gf180mcu_fd_sc_mcu7t5v0__and4_1
X_11_ bp[3] bp[2] _02_ _03_ _04_ VDD VDD VSS VSS gf180mcu_fd_sc_mcu7t5v0__nand4_1
X_12_ bp[9] bp[8] bp[1] bp[0] _05_ VDD VDD VSS VSS gf180mcu_fd_sc_mcu7t5v0__nor4_1
X_13_ bp[5] bp[4] bp[7] bp[6] _06_ VDD VDD VSS VSS gf180mcu_fd_sc_mcu7t5v0__nor4_1
X_14_ _05_ _06_ _07_ VDD VDD VSS VSS gf180mcu_fd_sc_mcu7t5v0__nand2_1
X_15_ bp[3] bp[2] _07_ _04_ _01_ VDD VDD VSS VSS gf180mcu_fd_sc_mcu7t5v0__oai31_1
X_16_ en done done_o VDD VDD VSS VSS gf180mcu_fd_sc_mcu7t5v0__and2_1
X_17_ bp[9] en done code_tc[0] VDD VDD VSS VSS gf180mcu_fd_sc_mcu7t5v0__dffrnq_1
X_18_ bp[8] en done code_tc[1] VDD VDD VSS VSS gf180mcu_fd_sc_mcu7t5v0__dffrnq_1
X_19_ bp[7] en done code_tc[2] VDD VDD VSS VSS gf180mcu_fd_sc_mcu7t5v0__dffrnq_1
X_20_ bp[6] en done code_tc[3] VDD VDD VSS VSS gf180mcu_fd_sc_mcu7t5v0__dffrnq_1
X_21_ bp[5] en done code_tc[4] VDD VDD VSS VSS gf180mcu_fd_sc_mcu7t5v0__dffrnq_1
X_22_ bp[4] en done code_tc[5] VDD VDD VSS VSS gf180mcu_fd_sc_mcu7t5v0__dffrnq_1
X_23_ bp[3] en done code_tc[6] VDD VDD VSS VSS gf180mcu_fd_sc_mcu7t5v0__dffrnq_1
X_24_ bp[2] en done code_tc[7] VDD VDD VSS VSS gf180mcu_fd_sc_mcu7t5v0__dffrnq_1
X_25_ bp[1] en done code_tc[8] VDD VDD VSS VSS gf180mcu_fd_sc_mcu7t5v0__dffrnq_1
X_26_ _00_ en done code_tc[9] VDD VDD VSS VSS gf180mcu_fd_sc_mcu7t5v0__dffrnq_1
X_27_ _01_ en done overload VDD VDD VSS VSS gf180mcu_fd_sc_mcu7t5v0__dffrnq_1
.ends

.subckt pt_adc_q VDD VSS INP INN VCM VREF IBIAS CLK ACQ0 ACQ1 EN ILEN TEST0 TEST1 CODE0 CODE1 CODE2 CODE3 CODE4 CODE5 CODE6 CODE7 CODE8 CODE9 DONE OVERLOAD CODEB0 CODEB1 CODEB2 CODEB3 CODEB4 CODEB5 CODEB6 CODEB7 CODEB8 CODEB9 DONEB OVERLOADB ATB_BIAS PH
XIEN_0 ENB EN VSS VSS nfet_03v3 w=1.0u l=0.28u
XIEP_0 ENB EN VDD VDD pfet_03v3 w=2.0u l=0.28u
XBSW_0 IBIAS EN ATB_BIAS VSS nfet_03v3 w=4u l=0.5u
XBD_0 ATB_BIAS ATB_BIAS VSS VSS nfet_03v3 w=4u l=2u
XBPD_0 ATB_BIAS ENB VSS VSS nfet_03v3 w=1u l=0.5u
XKI1NA_0 Kcb CLK KI1_m VSS nfet_03v3 w=4u l=0.28u
XKI1NB_0 KI1_m EN_D VSS VSS nfet_03v3 w=4u l=0.28u
XKI1PA_0 Kcb CLK VDD VDD pfet_03v3 w=4u l=0.28u
XKI1PB_0 Kcb EN_D VDD VDD pfet_03v3 w=4u l=0.28u
XKI2N_0 Kc Kcb VSS VSS nfet_03v3 w=2u l=0.28u
XKI2P_0 Kc Kcb VDD VDD pfet_03v3 w=4u l=0.28u
XKD0N0_0 KD0_0 Kc VSS VSS nfet_03v3 w=1u l=1.9u
XKD0P0_0 KD0_0 Kc VDD VDD pfet_03v3 w=2u l=1.9u
XKD0N1_0 KD0_1 KD0_0 VSS VSS nfet_03v3 w=1u l=1.9u
XKD0P1_0 KD0_1 KD0_0 VDD VDD pfet_03v3 w=2u l=1.9u
XKD0N2_0 KD0_2 KD0_1 VSS VSS nfet_03v3 w=1u l=1.9u
XKD0P2_0 KD0_2 KD0_1 VDD VDD pfet_03v3 w=2u l=1.9u
XKD0N3_0 Kt0 KD0_2 VSS VSS nfet_03v3 w=1u l=1.9u
XKD0P3_0 Kt0 KD0_2 VDD VDD pfet_03v3 w=2u l=1.9u
XKD1N0_0 KD1_0 Kt0 VSS VSS nfet_03v3 w=1u l=1.9u
XKD1P0_0 KD1_0 Kt0 VDD VDD pfet_03v3 w=2u l=1.9u
XKD1N1_0 Kt1 KD1_0 VSS VSS nfet_03v3 w=1u l=1.9u
XKD1P1_0 Kt1 KD1_0 VDD VDD pfet_03v3 w=2u l=1.9u
XKD2N0_0 KD2_0 Kt1 VSS VSS nfet_03v3 w=1u l=1.9u
XKD2P0_0 KD2_0 Kt1 VDD VDD pfet_03v3 w=2u l=1.9u
XKD2N1_0 Kt2 KD2_0 VSS VSS nfet_03v3 w=1u l=1.9u
XKD2P1_0 Kt2 KD2_0 VDD VDD pfet_03v3 w=2u l=1.9u
XKA0N_0 Ka0b ACQ0 VSS VSS nfet_03v3 w=1.0u l=0.28u
XKA0P_0 Ka0b ACQ0 VDD VDD pfet_03v3 w=2.0u l=0.28u
XKA1N_0 Ka1b ACQ1 VSS VSS nfet_03v3 w=1.0u l=0.28u
XKA1P_0 Ka1b ACQ1 VDD VDD pfet_03v3 w=2.0u l=0.28u
XKS0NA_0 Ks0 ACQ0 VSS VSS nfet_03v3 w=1.0u l=0.28u
XKS0NB_0 Ks0 ACQ1 VSS VSS nfet_03v3 w=1.0u l=0.28u
XKS0PA_0 KS0_m ACQ0 VDD VDD pfet_03v3 w=4.0u l=0.28u
XKS0PB_0 Ks0 ACQ1 KS0_m VDD pfet_03v3 w=4.0u l=0.28u
XKS1NA_0 Ks1 Ka0b VSS VSS nfet_03v3 w=1.0u l=0.28u
XKS1NB_0 Ks1 ACQ1 VSS VSS nfet_03v3 w=1.0u l=0.28u
XKS1PA_0 KS1_m Ka0b VDD VDD pfet_03v3 w=4.0u l=0.28u
XKS1PB_0 Ks1 ACQ1 KS1_m VDD pfet_03v3 w=4.0u l=0.28u
XKS2NA_0 Ks2 ACQ0 VSS VSS nfet_03v3 w=1.0u l=0.28u
XKS2NB_0 Ks2 Ka1b VSS VSS nfet_03v3 w=1.0u l=0.28u
XKS2PA_0 KS2_m ACQ0 VDD VDD pfet_03v3 w=4.0u l=0.28u
XKS2PB_0 Ks2 Ka1b KS2_m VDD pfet_03v3 w=4.0u l=0.28u
XKM0NA_0 Km0 Kt1 KM0_m VSS nfet_03v3 w=2.0u l=0.28u
XKM0NB_0 KM0_m Ks0 VSS VSS nfet_03v3 w=2.0u l=0.28u
XKM0PA_0 Km0 Kt1 VDD VDD pfet_03v3 w=2.0u l=0.28u
XKM0PB_0 Km0 Ks0 VDD VDD pfet_03v3 w=2.0u l=0.28u
XKM1NA_0 Km1 Kt0 KM1_m VSS nfet_03v3 w=2.0u l=0.28u
XKM1NB_0 KM1_m Ks1 VSS VSS nfet_03v3 w=2.0u l=0.28u
XKM1PA_0 Km1 Kt0 VDD VDD pfet_03v3 w=2.0u l=0.28u
XKM1PB_0 Km1 Ks1 VDD VDD pfet_03v3 w=2.0u l=0.28u
XKM2NA_0 Km2 Kt2 KM2_m VSS nfet_03v3 w=2.0u l=0.28u
XKM2NB_0 KM2_m Ks2 VSS VSS nfet_03v3 w=2.0u l=0.28u
XKM2PA_0 Km2 Kt2 VDD VDD pfet_03v3 w=2.0u l=0.28u
XKM2PB_0 Km2 Ks2 VDD VDD pfet_03v3 w=2.0u l=0.28u
XKMXNA_0 Kdl Km0 KMX_m1 VSS nfet_03v3 w=3.0u l=0.28u
XKMXNB_0 KMX_m1 Km1 KMX_m2 VSS nfet_03v3 w=3.0u l=0.28u
XKMXNC_0 KMX_m2 Km2 VSS VSS nfet_03v3 w=3.0u l=0.28u
XKMXPA_0 Kdl Km0 VDD VDD pfet_03v3 w=2.0u l=0.28u
XKMXPB_0 Kdl Km1 VDD VDD pfet_03v3 w=2.0u l=0.28u
XKMXPC_0 Kdl Km2 VDD VDD pfet_03v3 w=2.0u l=0.28u
XKPNA_0 Ky2 Kcb VSS VSS nfet_03v3 w=2u l=0.28u
XKPNB_0 Ky2 Kdl VSS VSS nfet_03v3 w=2u l=0.28u
XKPPA_0 KP_m Kcb VDD VDD pfet_03v3 w=8u l=0.28u
XKPPB_0 Ky2 Kdl KP_m VDD pfet_03v3 w=8u l=0.28u
XKGNA_0 Kz Ky2 KG_m VSS nfet_03v3 w=2.0u l=0.28u
XKGNB_0 KG_m EN_D VSS VSS nfet_03v3 w=2.0u l=0.28u
XKGPA_0 Kz Ky2 VDD VDD pfet_03v3 w=2.0u l=0.28u
XKGPB_0 Kz EN_D VDD VDD pfet_03v3 w=2.0u l=0.28u
XKI3N_0 SAMPLE Kz VSS VSS nfet_03v3 w=2u l=0.28u
XKI3P_0 SAMPLE Kz VDD VDD pfet_03v3 w=4u l=0.28u
XEDLN0_0 EDL_0 EN VSS VSS nfet_03v3 w=1u l=4.0u
XEDLP0_0 EDL_0 EN VDD VDD pfet_03v3 w=2u l=4.0u
XEDLN1_0 EDL_1 EDL_0 VSS VSS nfet_03v3 w=1u l=4.0u
XEDLP1_0 EDL_1 EDL_0 VDD VDD pfet_03v3 w=2u l=4.0u
XEDLN2_0 EDL_2 EDL_1 VSS VSS nfet_03v3 w=1u l=4.0u
XEDLP2_0 EDL_2 EDL_1 VDD VDD pfet_03v3 w=2u l=4.0u
XEDLN3_0 EN_D EDL_2 VSS VSS nfet_03v3 w=1u l=4.0u
XEDLP3_0 EN_D EDL_2 VDD VDD pfet_03v3 w=2u l=4.0u
XILGNA_0 ENB_B EN ILG_m VSS nfet_03v3 w=2.0u l=0.28u
XILGNB_0 ILG_m ILEN VSS VSS nfet_03v3 w=2.0u l=0.28u
XILGPA_0 ENB_B EN VDD VDD pfet_03v3 w=2.0u l=0.28u
XILGPB_0 ENB_B ILEN VDD VDD pfet_03v3 w=2.0u l=0.28u
XILIN_0 EN_B ENB_B VSS VSS nfet_03v3 w=2u l=0.28u
XILIP_0 EN_B ENB_B VDD VDD pfet_03v3 w=4u l=0.28u
XTCKN_0 SCK SAMPLE VSS VSS nfet_03v3 w=2u l=0.28u
XTCKP_0 SCK SAMPLE VDD VDD pfet_03v3 w=4u l=0.28u
XTFG1NA_0 TFo1 TFo4 TFG1_m VSS nfet_03v3 w=2.0u l=0.28u
XTFG1NB_0 TFG1_m TFo2 VSS VSS nfet_03v3 w=2.0u l=0.28u
XTFG1PA_0 TFo1 TFo4 VDD VDD pfet_03v3 w=2.0u l=0.28u
XTFG1PB_0 TFo1 TFo2 VDD VDD pfet_03v3 w=2.0u l=0.28u
XTFG2NA_0 TFo2 TFo1 TFG2_m1 VSS nfet_03v3 w=3.0u l=0.28u
XTFG2NB_0 TFG2_m1 EN_B TFG2_m2 VSS nfet_03v3 w=3.0u l=0.28u
XTFG2NC_0 TFG2_m2 SCK VSS VSS nfet_03v3 w=3.0u l=0.28u
XTFG2PA_0 TFo2 TFo1 VDD VDD pfet_03v3 w=2.0u l=0.28u
XTFG2PB_0 TFo2 EN_B VDD VDD pfet_03v3 w=2.0u l=0.28u
XTFG2PC_0 TFo2 SCK VDD VDD pfet_03v3 w=2.0u l=0.28u
XTFG3NA_0 TFo3 TFo2 TFG3_m1 VSS nfet_03v3 w=3.0u l=0.28u
XTFG3NB_0 TFG3_m1 SCK TFG3_m2 VSS nfet_03v3 w=3.0u l=0.28u
XTFG3NC_0 TFG3_m2 TFo4 VSS VSS nfet_03v3 w=3.0u l=0.28u
XTFG3PA_0 TFo3 TFo2 VDD VDD pfet_03v3 w=2.0u l=0.28u
XTFG3PB_0 TFo3 SCK VDD VDD pfet_03v3 w=2.0u l=0.28u
XTFG3PC_0 TFo3 TFo4 VDD VDD pfet_03v3 w=2.0u l=0.28u
XTFG4NA_0 TFo4 TFo3 TFG4_m1 VSS nfet_03v3 w=3.0u l=0.28u
XTFG4NB_0 TFG4_m1 EN_B TFG4_m2 VSS nfet_03v3 w=3.0u l=0.28u
XTFG4NC_0 TFG4_m2 PHB VSS VSS nfet_03v3 w=3.0u l=0.28u
XTFG4PA_0 TFo4 TFo3 VDD VDD pfet_03v3 w=2.0u l=0.28u
XTFG4PB_0 TFo4 EN_B VDD VDD pfet_03v3 w=2.0u l=0.28u
XTFG4PC_0 TFo4 PHB VDD VDD pfet_03v3 w=2.0u l=0.28u
XTFG5NA_0 PH TFo2 TFG5_m VSS nfet_03v3 w=3u l=0.28u
XTFG5NB_0 TFG5_m PHB VSS VSS nfet_03v3 w=3u l=0.28u
XTFG5PA_0 PH TFo2 VDD VDD pfet_03v3 w=3u l=0.28u
XTFG5PB_0 PH PHB VDD VDD pfet_03v3 w=3u l=0.28u
XTFG6NA_0 PHB PH TFG6_m1 VSS nfet_03v3 w=3.0u l=0.28u
XTFG6NB_0 TFG6_m1 TFo3 TFG6_m2 VSS nfet_03v3 w=3.0u l=0.28u
XTFG6NC_0 TFG6_m2 EN_B VSS VSS nfet_03v3 w=3.0u l=0.28u
XTFG6PA_0 PHB PH VDD VDD pfet_03v3 w=2.0u l=0.28u
XTFG6PB_0 PHB TFo3 VDD VDD pfet_03v3 w=2.0u l=0.28u
XTFG6PC_0 PHB EN_B VDD VDD pfet_03v3 w=2.0u l=0.28u
XSGANA_0 SAB_A SAMPLE SGA_m VSS nfet_03v3 w=4u l=0.28u
XSGANB_0 SGA_m PHB VSS VSS nfet_03v3 w=4u l=0.28u
XSGAPA_0 SAB_A SAMPLE VDD VDD pfet_03v3 w=4u l=0.28u
XSGAPB_0 SAB_A PHB VDD VDD pfet_03v3 w=4u l=0.28u
XSIAN_0 SAMPLE_A SAB_A VSS VSS nfet_03v3 w=4u l=0.28u
XSIAP_0 SAMPLE_A SAB_A VDD VDD pfet_03v3 w=8u l=0.28u
XSGBNA_0 SAB_B SAMPLE SGB_m VSS nfet_03v3 w=4u l=0.28u
XSGBNB_0 SGB_m PH VSS VSS nfet_03v3 w=4u l=0.28u
XSGBPA_0 SAB_B SAMPLE VDD VDD pfet_03v3 w=4u l=0.28u
XSGBPB_0 SAB_B PH VDD VDD pfet_03v3 w=4u l=0.28u
XSIBN_0 SAMPLE_B SAB_B VSS VSS nfet_03v3 w=4u l=0.28u
XSIBP_0 SAMPLE_B SAB_B VDD VDD pfet_03v3 w=8u l=0.28u
XGTZNA_A_0 TZ_A TEST0 VSS VSS nfet_03v3 w=1.0u l=0.28u
XGTZNB_A_0 TZ_A TEST1 VSS VSS nfet_03v3 w=1.0u l=0.28u
XGTZPA_A_0 GTZ_m_A TEST0 VDD VDD pfet_03v3 w=4.0u l=0.28u
XGTZPB_A_0 TZ_A TEST1 GTZ_m_A VDD pfet_03v3 w=4.0u l=0.28u
XGTZBN_A_0 TZB_A TZ_A VSS VSS nfet_03v3 w=1.0u l=0.28u
XGTZBP_A_0 TZB_A TZ_A VDD VDD pfet_03v3 w=2.0u l=0.28u
XGSENA_A_0 SEB_A SAMPLE_A GSE_m_A VSS nfet_03v3 w=2.0u l=0.28u
XGSENB_A_0 GSE_m_A EN VSS VSS nfet_03v3 w=2.0u l=0.28u
XGSEPA_A_0 SEB_A SAMPLE_A VDD VDD pfet_03v3 w=2.0u l=0.28u
XGSEPB_A_0 SEB_A EN VDD VDD pfet_03v3 w=2.0u l=0.28u
XGSEIN_A_0 SEN_A SEB_A VSS VSS nfet_03v3 w=2u l=0.28u
XGSEIP_A_0 SEN_A SEB_A VDD VDD pfet_03v3 w=4u l=0.28u
XGBTNA_A_0 BOOTBL_A SEN_A GBT_m_A VSS nfet_03v3 w=4u l=0.28u
XGBTNB_A_0 GBT_m_A TZ_A VSS VSS nfet_03v3 w=4u l=0.28u
XGBTPA_A_0 BOOTBL_A SEN_A VDD VDD pfet_03v3 w=4u l=0.28u
XGBTPB_A_0 BOOTBL_A TZ_A VDD VDD pfet_03v3 w=4u l=0.28u
XGBTIN_A_0 BOOTL_A BOOTBL_A VSS VSS nfet_03v3 w=4u l=0.28u
XGBTIP_A_0 BOOTL_A BOOTBL_A VDD VDD pfet_03v3 w=8u l=0.28u
XGVTNA_A_0 VCMTB_A SEN_A GVT_m_A VSS nfet_03v3 w=2.0u l=0.28u
XGVTNB_A_0 GVT_m_A TZB_A VSS VSS nfet_03v3 w=2.0u l=0.28u
XGVTPA_A_0 VCMTB_A SEN_A VDD VDD pfet_03v3 w=2.0u l=0.28u
XGVTPB_A_0 VCMTB_A TZB_A VDD VDD pfet_03v3 w=2.0u l=0.28u
XGVTIN_A_0 VCMTL_A VCMTB_A VSS VSS nfet_03v3 w=2u l=0.28u
XGVTIP_A_0 VCMTL_A VCMTB_A VDD VDD pfet_03v3 w=4u l=0.28u
XGLRAN_A_0 LSBRB_A SEN_A VSS VSS nfet_03v3 w=1.0u l=0.28u
XGLRAP_A_0 LSBRB_A SEN_A VDD VDD pfet_03v3 w=2.0u l=0.28u
XGLRBN_A_0 LSBRL_A LSBRB_A VSS VSS nfet_03v3 w=2u l=0.28u
XGLRBP_A_0 LSBRL_A LSBRB_A VDD VDD pfet_03v3 w=4u l=0.28u
XSPMS_A_0 INP SPg_A TOPP_A VSS nfet_03v3 w=8u l=0.28u
XSPCB_A_0 SPtb_A SPbb_A cap_mim_2f0_m4m5_noshield c_width=10u c_length=10u
XSPM1_A_0 SPbb_A BOOTBL_A VSS VSS nfet_03v3 w=2u l=0.28u
XSPM2_A_0 SPtb_A SPg_A VDD SPtb_A pfet_03v3 w=2u l=0.28u
XSPM3_A_0 SPg_A SPh_A SPtb_A SPtb_A pfet_03v3 w=4u l=0.28u
XSPM4_A_0 SPh_A BOOTL_A SPbb_A VSS nfet_03v3 w=1u l=0.28u
XSPM5_A_0 SPh_A BOOTL_A VDD VDD pfet_03v3 w=1u l=0.28u
XSPM6_A_0 SPbb_A SPg_A INP VSS nfet_03v3 w=4u l=0.28u
XSPM7_A_0 SPg_A VDD SPgx_A VSS nfet_03v3 w=2u l=0.28u
XSPM8_A_0 SPgx_A BOOTBL_A VSS VSS nfet_03v3 w=2u l=0.28u
XVTP_A_0 TOPP_A VCMTL_A VCM VSS nfet_03v3 w=2u l=0.28u
XLRP_A_0 LSBP_A LSBRL_A VCM VSS nfet_03v3 w=1u l=0.28u
XSNMS_A_0 INN SNg_A TOPN_A VSS nfet_03v3 w=8u l=0.28u
XSNCB_A_0 SNtb_A SNbb_A cap_mim_2f0_m4m5_noshield c_width=10u c_length=10u
XSNM1_A_0 SNbb_A BOOTBL_A VSS VSS nfet_03v3 w=2u l=0.28u
XSNM2_A_0 SNtb_A SNg_A VDD SNtb_A pfet_03v3 w=2u l=0.28u
XSNM3_A_0 SNg_A SNh_A SNtb_A SNtb_A pfet_03v3 w=4u l=0.28u
XSNM4_A_0 SNh_A BOOTL_A SNbb_A VSS nfet_03v3 w=1u l=0.28u
XSNM5_A_0 SNh_A BOOTL_A VDD VDD pfet_03v3 w=1u l=0.28u
XSNM6_A_0 SNbb_A SNg_A INN VSS nfet_03v3 w=4u l=0.28u
XSNM7_A_0 SNg_A VDD SNgx_A VSS nfet_03v3 w=2u l=0.28u
XSNM8_A_0 SNgx_A BOOTBL_A VSS VSS nfet_03v3 w=2u l=0.28u
XVTN_A_0 TOPN_A VCMTL_A VCM VSS nfet_03v3 w=2u l=0.28u
XLRN_A_0 LSBN_A LSBRL_A VCM VSS nfet_03v3 w=1u l=0.28u
XQB1N_A_0 Qckb_A CMPCLK_A VSS VSS nfet_03v3 w=3u l=0.28u
XQB1P_A_0 Qckb_A CMPCLK_A VDD VDD pfet_03v3 w=6u l=0.28u
XQB2N_A_0 Qck_A Qckb_A VSS VSS nfet_03v3 w=12u l=0.28u
XQB2P_A_0 Qck_A Qckb_A VDD VDD pfet_03v3 w=12.0u l=0.28u
XQB2P_A_1 Qck_A Qckb_A VDD VDD pfet_03v3 w=12.0u l=0.28u
XQMT_A_0 Qct_A Qck_A VSS VSS nfet_03v3 w=12u l=0.28u
XQMIP_A_0 Qcn1_A TOPP_A Qct_A VSS nfet_03v3 w=8u l=0.28u
XQMIN_A_0 Qcn2_A TOPN_A Qct_A VSS nfet_03v3 w=8u l=0.28u
XQMNP_A_0 Qqn_A Qqp_A Qcn1_A VSS nfet_03v3 w=8u l=0.28u
XQMNN_A_0 Qqp_A Qqn_A Qcn2_A VSS nfet_03v3 w=8u l=0.28u
XQMPP_A_0 Qqn_A Qqp_A VDD VDD pfet_03v3 w=8u l=0.28u
XQMPN_A_0 Qqp_A Qqn_A VDD VDD pfet_03v3 w=8u l=0.28u
XQMR1_A_0 Qcn1_A Qck_A VDD VDD pfet_03v3 w=4u l=0.28u
XQMR2_A_0 Qcn2_A Qck_A VDD VDD pfet_03v3 w=4u l=0.28u
XQMRP_A_0 Qqp_A Qck_A VDD VDD pfet_03v3 w=4u l=0.28u
XQMRN_A_0 Qqn_A Qck_A VDD VDD pfet_03v3 w=4u l=0.28u
XQIPN_A_0 DP_A Qqn_A VSS VSS nfet_03v3 w=6u l=0.28u
XQIPP_A_0 DP_A Qqn_A VDD VDD pfet_03v3 w=12u l=0.28u
XQINN_A_0 DN_A Qqp_A VSS VSS nfet_03v3 w=6u l=0.28u
XQINP_A_0 DN_A Qqp_A VDD VDD pfet_03v3 w=12u l=0.28u
XMGP0_A_0 BOTP0_A GP0_A VSS VSS nfet_03v3 w=1u l=0.28u
XMRP0_A_0 BOTP0_A RP0_A VREF VSS nfet_03v3 w=1u l=0.28u
XMGP1_A_0 BOTP1_A GP1_A VSS VSS nfet_03v3 w=1u l=0.28u
XMRP1_A_0 BOTP1_A RP1_A VREF VSS nfet_03v3 w=1u l=0.28u
XMGP2_A_0 BOTP2_A GP2_A VSS VSS nfet_03v3 w=1.2u l=0.28u
XMRP2_A_0 BOTP2_A RP2_A VREF VSS nfet_03v3 w=1.2u l=0.28u
XMGP3_A_0 BOTP3_A GP3_A VSS VSS nfet_03v3 w=2.5u l=0.28u
XMRP3_A_0 BOTP3_A RP3_A VREF VSS nfet_03v3 w=2.5u l=0.28u
XMGP4_A_0 BOTP4_A GP4_A VSS VSS nfet_03v3 w=5u l=0.28u
XMRP4_A_0 BOTP4_A RP4_A VREF VSS nfet_03v3 w=5u l=0.28u
XMGP5_A_0 BOTP5_A GP5_A VSS VSS nfet_03v3 w=10u l=0.28u
XMRP5_A_0 BOTP5_A RP5_A VREF VSS nfet_03v3 w=10u l=0.28u
XMGP6_A_0 BOTP6_A GP6_A VSS VSS nfet_03v3 w=1u l=0.28u
XMRP6_A_0 BOTP6_A RP6_A VREF VSS nfet_03v3 w=1u l=0.28u
XMGP7_A_0 BOTP7_A GP7_A VSS VSS nfet_03v3 w=2u l=0.28u
XMRP7_A_0 BOTP7_A RP7_A VREF VSS nfet_03v3 w=2u l=0.28u
XMGP8_A_0 BOTP8_A GP8_A VSS VSS nfet_03v3 w=4u l=0.28u
XMRP8_A_0 BOTP8_A RP8_A VREF VSS nfet_03v3 w=4u l=0.28u
XMGN0_A_0 BOTN0_A GN0_A VSS VSS nfet_03v3 w=1u l=0.28u
XMRN0_A_0 BOTN0_A RN0_A VREF VSS nfet_03v3 w=1u l=0.28u
XMGN1_A_0 BOTN1_A GN1_A VSS VSS nfet_03v3 w=1u l=0.28u
XMRN1_A_0 BOTN1_A RN1_A VREF VSS nfet_03v3 w=1u l=0.28u
XMGN2_A_0 BOTN2_A GN2_A VSS VSS nfet_03v3 w=1.2u l=0.28u
XMRN2_A_0 BOTN2_A RN2_A VREF VSS nfet_03v3 w=1.2u l=0.28u
XMGN3_A_0 BOTN3_A GN3_A VSS VSS nfet_03v3 w=2.5u l=0.28u
XMRN3_A_0 BOTN3_A RN3_A VREF VSS nfet_03v3 w=2.5u l=0.28u
XMGN4_A_0 BOTN4_A GN4_A VSS VSS nfet_03v3 w=5u l=0.28u
XMRN4_A_0 BOTN4_A RN4_A VREF VSS nfet_03v3 w=5u l=0.28u
XMGN5_A_0 BOTN5_A GN5_A VSS VSS nfet_03v3 w=10u l=0.28u
XMRN5_A_0 BOTN5_A RN5_A VREF VSS nfet_03v3 w=10u l=0.28u
XMGN6_A_0 BOTN6_A GN6_A VSS VSS nfet_03v3 w=1u l=0.28u
XMRN6_A_0 BOTN6_A RN6_A VREF VSS nfet_03v3 w=1u l=0.28u
XMGN7_A_0 BOTN7_A GN7_A VSS VSS nfet_03v3 w=2u l=0.28u
XMRN7_A_0 BOTN7_A RN7_A VREF VSS nfet_03v3 w=2u l=0.28u
XMGN8_A_0 BOTN8_A GN8_A VSS VSS nfet_03v3 w=4u l=0.28u
XMRN8_A_0 BOTN8_A RN8_A VREF VSS nfet_03v3 w=4u l=0.28u
XCP8_A_0 TOPP_A BOTP8_A cap_mim_2f0_m4m5_noshield c_width=5u c_length=5u
XCP8_A_1 TOPP_A BOTP8_A cap_mim_2f0_m4m5_noshield c_width=5u c_length=5u
XCP8_A_2 TOPP_A BOTP8_A cap_mim_2f0_m4m5_noshield c_width=5u c_length=5u
XCP8_A_3 TOPP_A BOTP8_A cap_mim_2f0_m4m5_noshield c_width=5u c_length=5u
XCP7_A_0 TOPP_A BOTP7_A cap_mim_2f0_m4m5_noshield c_width=5u c_length=5u
XCP7_A_1 TOPP_A BOTP7_A cap_mim_2f0_m4m5_noshield c_width=5u c_length=5u
XCP6_A_0 TOPP_A BOTP6_A cap_mim_2f0_m4m5_noshield c_width=5u c_length=5u
XCBP_A_0 LSBP_A TOPP_A cap_mim_2f0_m4m5_noshield c_width=5.04u c_length=5.04u
XCP5_A_0 LSBP_A BOTP5_A cap_mim_2f0_m4m5_noshield c_width=29.37u c_length=29.37u
XCP4_A_0 LSBP_A BOTP4_A cap_mim_2f0_m4m5_noshield c_width=20.695u c_length=20.695u
XCP3_A_0 LSBP_A BOTP3_A cap_mim_2f0_m4m5_noshield c_width=14.565u c_length=14.565u
XCP2_A_0 LSBP_A BOTP2_A cap_mim_2f0_m4m5_noshield c_width=10.23u c_length=10.23u
XCP1_A_0 LSBP_A BOTP1_A cap_mim_2f0_m4m5_noshield c_width=7.165u c_length=7.165u
XCP0_A_0 LSBP_A BOTP0_A cap_mim_2f0_m4m5_noshield c_width=5.0u c_length=5.0u
XCDP_A_0 LSBP_A VSS cap_mim_2f0_m4m5_noshield c_width=5u c_length=5u
XCN8_A_0 TOPN_A BOTN8_A cap_mim_2f0_m4m5_noshield c_width=5u c_length=5u
XCN8_A_1 TOPN_A BOTN8_A cap_mim_2f0_m4m5_noshield c_width=5u c_length=5u
XCN8_A_2 TOPN_A BOTN8_A cap_mim_2f0_m4m5_noshield c_width=5u c_length=5u
XCN8_A_3 TOPN_A BOTN8_A cap_mim_2f0_m4m5_noshield c_width=5u c_length=5u
XCN7_A_0 TOPN_A BOTN7_A cap_mim_2f0_m4m5_noshield c_width=5u c_length=5u
XCN7_A_1 TOPN_A BOTN7_A cap_mim_2f0_m4m5_noshield c_width=5u c_length=5u
XCN6_A_0 TOPN_A BOTN6_A cap_mim_2f0_m4m5_noshield c_width=5u c_length=5u
XCBN_A_0 LSBN_A TOPN_A cap_mim_2f0_m4m5_noshield c_width=5.04u c_length=5.04u
XCN5_A_0 LSBN_A BOTN5_A cap_mim_2f0_m4m5_noshield c_width=29.37u c_length=29.37u
XCN4_A_0 LSBN_A BOTN4_A cap_mim_2f0_m4m5_noshield c_width=20.695u c_length=20.695u
XCN3_A_0 LSBN_A BOTN3_A cap_mim_2f0_m4m5_noshield c_width=14.565u c_length=14.565u
XCN2_A_0 LSBN_A BOTN2_A cap_mim_2f0_m4m5_noshield c_width=10.23u c_length=10.23u
XCN1_A_0 LSBN_A BOTN1_A cap_mim_2f0_m4m5_noshield c_width=7.165u c_length=7.165u
XCN0_A_0 LSBN_A BOTN0_A cap_mim_2f0_m4m5_noshield c_width=5.0u c_length=5.0u
XCDN_A_0 LSBN_A VSS cap_mim_2f0_m4m5_noshield c_width=5u c_length=5u
XCRNA_A_0 R_A SEB_A CR_m_A VSS nfet_03v3 w=5.0u l=0.28u
XCRNB_A_0 CR_m_A EN VSS VSS nfet_03v3 w=5.0u l=0.28u
XCRPA_A_0 R_A SEB_A VDD VDD pfet_03v3 w=5.0u l=0.28u
XCRPB_A_0 R_A EN VDD VDD pfet_03v3 w=5.0u l=0.28u
XCRBN_A_0 RB_A R_A VSS VSS nfet_03v3 w=2.5u l=0.28u
XCRBP_A_0 RB_A R_A VDD VDD pfet_03v3 w=5.0u l=0.28u
XDT1N0_A_0 DT1_0_A SEN_A VSS VSS nfet_03v3 w=2.5u l=0.28u
XDT1P0_A_0 DT1_0_A SEN_A VDD VDD pfet_03v3 w=5.0u l=0.28u
XDT1N1_A_0 SEN_d1_A DT1_0_A VSS VSS nfet_03v3 w=2.5u l=0.28u
XDT1P1_A_0 SEN_d1_A DT1_0_A VDD VDD pfet_03v3 w=5.0u l=0.28u
XOT1NA_A_0 TD1B_A SEN_A VSS VSS nfet_03v3 w=2.5u l=0.28u
XOT1NB_A_0 TD1B_A SEN_d1_A VSS VSS nfet_03v3 w=2.5u l=0.28u
XOT1PA_A_0 OT1_m_A SEN_A VDD VDD pfet_03v3 w=10.0u l=0.28u
XOT1PB_A_0 TD1B_A SEN_d1_A OT1_m_A VDD pfet_03v3 w=10.0u l=0.28u
XDT2N0_A_0 DT2_0_A SEN_d1_A VSS VSS nfet_03v3 w=2.5u l=0.28u
XDT2P0_A_0 DT2_0_A SEN_d1_A VDD VDD pfet_03v3 w=5.0u l=0.28u
XDT2N1_A_0 SEN_d2_A DT2_0_A VSS VSS nfet_03v3 w=2.5u l=0.28u
XDT2P1_A_0 SEN_d2_A DT2_0_A VDD VDD pfet_03v3 w=5.0u l=0.28u
XOT2NA_A_0 TD2B_A SEN_A VSS VSS nfet_03v3 w=2.5u l=0.28u
XOT2NB_A_0 TD2B_A SEN_d1_A VSS VSS nfet_03v3 w=2.5u l=0.28u
XOT2NC_A_0 TD2B_A SEN_d2_A VSS VSS nfet_03v3 w=2.5u l=0.28u
XOT2PA_A_0 OT2_m1_A SEN_A VDD VDD pfet_03v3 w=15.0u l=0.28u
XOT2PB_A_0 OT2_m2_A SEN_d1_A OT2_m1_A VDD pfet_03v3 w=15.0u l=0.28u
XOT2PC_A_0 TD2B_A SEN_d2_A OT2_m2_A VDD pfet_03v3 w=15.0u l=0.28u
XIT2N_A_0 TD2_A TD2B_A VSS VSS nfet_03v3 w=2.5u l=0.28u
XIT2P_A_0 TD2_A TD2B_A VDD VDD pfet_03v3 w=5.0u l=0.28u
XORNNA_A_0 RUN_A TD2_A VSS VSS nfet_03v3 w=2.5u l=0.28u
XORNNB_A_0 RUN_A D9_A VSS VSS nfet_03v3 w=2.5u l=0.28u
XORNNC_A_0 RUN_A ENB VSS VSS nfet_03v3 w=2.5u l=0.28u
XORNPA_A_0 ORN_m1_A TD2_A VDD VDD pfet_03v3 w=15.0u l=0.28u
XORNPB_A_0 ORN_m2_A D9_A ORN_m1_A VDD pfet_03v3 w=15.0u l=0.28u
XORNPC_A_0 RUN_A ENB ORN_m2_A VDD pfet_03v3 w=15.0u l=0.28u
XIRNN_A_0 RUNB_A RUN_A VSS VSS nfet_03v3 w=2.5u l=0.28u
XIRNP_A_0 RUNB_A RUN_A VDD VDD pfet_03v3 w=5.0u l=0.28u
XOVNA_A_0 VALIDB_A DP_A VSS VSS nfet_03v3 w=5.0u l=0.28u
XOVNB_A_0 VALIDB_A DN_A VSS VSS nfet_03v3 w=5.0u l=0.28u
XOVPA_A_0 OV_m_A DP_A VDD VDD pfet_03v3 w=10.0u l=0.28u
XOVPA_A_1 OV_m_A DP_A VDD VDD pfet_03v3 w=10.0u l=0.28u
XOVPB_A_0 VALIDB_A DN_A OV_m_A VDD pfet_03v3 w=10.0u l=0.28u
XOVPB_A_1 VALIDB_A DN_A OV_m_A VDD pfet_03v3 w=10.0u l=0.28u
XIVN_A_0 VALID_A VALIDB_A VSS VSS nfet_03v3 w=5.0u l=0.28u
XIVP_A_0 VALID_A VALIDB_A VDD VDD pfet_03v3 w=10.0u l=0.28u
XIDPN_A_0 DPB_A DP_A VSS VSS nfet_03v3 w=5.0u l=0.28u
XIDPP_A_0 DPB_A DP_A VDD VDD pfet_03v3 w=10.0u l=0.28u
XIDNN_A_0 DNB_A DN_A VSS VSS nfet_03v3 w=5.0u l=0.28u
XIDNP_A_0 DNB_A DN_A VDD VDD pfet_03v3 w=10.0u l=0.28u
XOKNA_A_0 CMPCLK_A DP_A VSS VSS nfet_03v3 w=5.0u l=0.28u
XOKNB_A_0 CMPCLK_A DN_A VSS VSS nfet_03v3 w=5.0u l=0.28u
XOKNC_A_0 CMPCLK_A RUNB_A VSS VSS nfet_03v3 w=5.0u l=0.28u
XOKPA_A_0 OK_m1_A DP_A VDD VDD pfet_03v3 w=15.0u l=0.28u
XOKPA_A_1 OK_m1_A DP_A VDD VDD pfet_03v3 w=15.0u l=0.28u
XOKPB_A_0 OK_m2_A DN_A OK_m1_A VDD pfet_03v3 w=15.0u l=0.28u
XOKPB_A_1 OK_m2_A DN_A OK_m1_A VDD pfet_03v3 w=15.0u l=0.28u
XOKPC_A_0 CMPCLK_A RUNB_A OK_m2_A VDD pfet_03v3 w=15.0u l=0.28u
XOKPC_A_1 CMPCLK_A RUNB_A OK_m2_A VDD pfet_03v3 w=15.0u l=0.28u
XIT0N_A_0 TEST0B_A TEST0 VSS VSS nfet_03v3 w=2.5u l=0.28u
XIT0P_A_0 TEST0B_A TEST0 VDD VDD pfet_03v3 w=5.0u l=0.28u
XIT1N_A_0 TEST1B_A TEST1 VSS VSS nfet_03v3 w=2.5u l=0.28u
XIT1P_A_0 TEST1B_A TEST1 VDD VDD pfet_03v3 w=5.0u l=0.28u
XOFPNA_A_0 FP_A TD1B_A VSS VSS nfet_03v3 w=2.5u l=0.28u
XOFPNB_A_0 FP_A TEST1B_A VSS VSS nfet_03v3 w=2.5u l=0.28u
XOFPNC_A_0 FP_A TEST0 VSS VSS nfet_03v3 w=2.5u l=0.28u
XOFPPA_A_0 OFP_m1_A TD1B_A VDD VDD pfet_03v3 w=15.0u l=0.28u
XOFPPB_A_0 OFP_m2_A TEST1B_A OFP_m1_A VDD pfet_03v3 w=15.0u l=0.28u
XOFPPC_A_0 FP_A TEST0 OFP_m2_A VDD pfet_03v3 w=15.0u l=0.28u
XOFNNA_A_0 FN_A TD1B_A VSS VSS nfet_03v3 w=2.5u l=0.28u
XOFNNB_A_0 FN_A TEST1B_A VSS VSS nfet_03v3 w=2.5u l=0.28u
XOFNNC_A_0 FN_A TEST0B_A VSS VSS nfet_03v3 w=2.5u l=0.28u
XOFNPA_A_0 OFN_m1_A TD1B_A VDD VDD pfet_03v3 w=15.0u l=0.28u
XOFNPB_A_0 OFN_m2_A TEST1B_A OFN_m1_A VDD pfet_03v3 w=15.0u l=0.28u
XOFNPC_A_0 FN_A TEST0B_A OFN_m2_A VDD pfet_03v3 w=15.0u l=0.28u
XK0_SNA_A_0 K0_SAB_A RUN_A K0_S_m_A VSS nfet_03v3 w=5.0u l=0.28u
XK0_SNB_A_0 K0_S_m_A VALIDB_A VSS VSS nfet_03v3 w=5.0u l=0.28u
XK0_SPA_A_0 K0_SAB_A RUN_A VDD VDD pfet_03v3 w=5.0u l=0.28u
XK0_SPB_A_0 K0_SAB_A VALIDB_A VDD VDD pfet_03v3 w=5.0u l=0.28u
XK0_LANA_A_0 K0_A_A K0_SAB_A K0_LA_m_A VSS nfet_03v3 w=5.0u l=0.28u
XK0_LANB_A_0 K0_LA_m_A K0_AB_A VSS VSS nfet_03v3 w=5.0u l=0.28u
XK0_LAPA_A_0 K0_A_A K0_SAB_A VDD VDD pfet_03v3 w=5.0u l=0.28u
XK0_LAPB_A_0 K0_A_A K0_AB_A VDD VDD pfet_03v3 w=5.0u l=0.28u
XK0_LBNA_A_0 K0_AB_A K0_A_A K0_LB_m_A VSS nfet_03v3 w=5.0u l=0.28u
XK0_LBNB_A_0 K0_LB_m_A RB_A VSS VSS nfet_03v3 w=5.0u l=0.28u
XK0_LBPA_A_0 K0_AB_A K0_A_A VDD VDD pfet_03v3 w=5.0u l=0.28u
XK0_LBPB_A_0 K0_AB_A RB_A VDD VDD pfet_03v3 w=5.0u l=0.28u
XK0_SPNA_A_0 K0_SETP_A K0_AB_A VSS VSS nfet_03v3 w=2.5u l=0.28u
XK0_SPNB_A_0 K0_SETP_A D0_A VSS VSS nfet_03v3 w=2.5u l=0.28u
XK0_SPNC_A_0 K0_SETP_A DPB_A VSS VSS nfet_03v3 w=2.5u l=0.28u
XK0_SPPA_A_0 K0_SP_m1_A K0_AB_A VDD VDD pfet_03v3 w=15.0u l=0.28u
XK0_SPPB_A_0 K0_SP_m2_A D0_A K0_SP_m1_A VDD pfet_03v3 w=15.0u l=0.28u
XK0_SPPC_A_0 K0_SETP_A DPB_A K0_SP_m2_A VDD pfet_03v3 w=15.0u l=0.28u
XK0_SNNA_A_0 K0_SETN_A K0_AB_A VSS VSS nfet_03v3 w=2.5u l=0.28u
XK0_SNNB_A_0 K0_SETN_A D0_A VSS VSS nfet_03v3 w=2.5u l=0.28u
XK0_SNNC_A_0 K0_SETN_A DNB_A VSS VSS nfet_03v3 w=2.5u l=0.28u
XK0_SNPA_A_0 K0_SN_m1_A K0_AB_A VDD VDD pfet_03v3 w=15.0u l=0.28u
XK0_SNPB_A_0 K0_SN_m2_A D0_A K0_SN_m1_A VDD pfet_03v3 w=15.0u l=0.28u
XK0_SNPC_A_0 K0_SETN_A DNB_A K0_SN_m2_A VDD pfet_03v3 w=15.0u l=0.28u
XK0_PANA_A_0 K0_QP_A R_A VSS VSS nfet_03v3 w=2.5u l=0.28u
XK0_PANB_A_0 K0_QP_A K0_QPB_A VSS VSS nfet_03v3 w=2.5u l=0.28u
XK0_PAPA_A_0 K0_PA_m_A R_A VDD VDD pfet_03v3 w=10.0u l=0.28u
XK0_PAPB_A_0 K0_QP_A K0_QPB_A K0_PA_m_A VDD pfet_03v3 w=10.0u l=0.28u
XK0_PBNA_A_0 K0_QPB_A K0_SETP_A VSS VSS nfet_03v3 w=2.5u l=0.28u
XK0_PBNB_A_0 K0_QPB_A K0_QP_A VSS VSS nfet_03v3 w=2.5u l=0.28u
XK0_PBPA_A_0 K0_PB_m_A K0_SETP_A VDD VDD pfet_03v3 w=10.0u l=0.28u
XK0_PBPB_A_0 K0_QPB_A K0_QP_A K0_PB_m_A VDD pfet_03v3 w=10.0u l=0.28u
XK0_NANA_A_0 K0_QN_A R_A VSS VSS nfet_03v3 w=2.5u l=0.28u
XK0_NANB_A_0 K0_QN_A K0_QNB_A VSS VSS nfet_03v3 w=2.5u l=0.28u
XK0_NAPA_A_0 K0_NA_m_A R_A VDD VDD pfet_03v3 w=10.0u l=0.28u
XK0_NAPB_A_0 K0_QN_A K0_QNB_A K0_NA_m_A VDD pfet_03v3 w=10.0u l=0.28u
XK0_NBNA_A_0 K0_QNB_A K0_SETN_A VSS VSS nfet_03v3 w=2.5u l=0.28u
XK0_NBNB_A_0 K0_QNB_A K0_QN_A VSS VSS nfet_03v3 w=2.5u l=0.28u
XK0_NBPA_A_0 K0_NB_m_A K0_SETN_A VDD VDD pfet_03v3 w=10.0u l=0.28u
XK0_NBPB_A_0 K0_QNB_A K0_QN_A K0_NB_m_A VDD pfet_03v3 w=10.0u l=0.28u
XK0_DNA_A_0 D0_A K0_QPB_A K0_D_m_A VSS nfet_03v3 w=5.0u l=0.28u
XK0_DNB_A_0 K0_D_m_A K0_QNB_A VSS VSS nfet_03v3 w=5.0u l=0.28u
XK0_DPA_A_0 D0_A K0_QPB_A VDD VDD pfet_03v3 w=5.0u l=0.28u
XK0_DPB_A_0 D0_A K0_QNB_A VDD VDD pfet_03v3 w=5.0u l=0.28u
XDGP8N_A_0 GP8_A K0_QPB_A VSS VSS nfet_03v3 w=5.0u l=0.28u
XDGP8P_A_0 GP8_A K0_QPB_A VDD VDD pfet_03v3 w=10.0u l=0.28u
XDRP8N_A_0 RP8_A K0_QP_A VSS VSS nfet_03v3 w=5.0u l=0.28u
XDRP8P_A_0 RP8_A K0_QP_A VDD VDD pfet_03v3 w=10.0u l=0.28u
XDGN8N_A_0 GN8_A K0_QNB_A VSS VSS nfet_03v3 w=5.0u l=0.28u
XDGN8P_A_0 GN8_A K0_QNB_A VDD VDD pfet_03v3 w=10.0u l=0.28u
XDRN8N_A_0 RN8_A K0_QN_A VSS VSS nfet_03v3 w=5.0u l=0.28u
XDRN8P_A_0 RN8_A K0_QN_A VDD VDD pfet_03v3 w=10.0u l=0.28u
XK1_SNA_A_0 K1_SAB_A D0_A K1_S_m_A VSS nfet_03v3 w=5.0u l=0.28u
XK1_SNB_A_0 K1_S_m_A VALIDB_A VSS VSS nfet_03v3 w=5.0u l=0.28u
XK1_SPA_A_0 K1_SAB_A D0_A VDD VDD pfet_03v3 w=5.0u l=0.28u
XK1_SPB_A_0 K1_SAB_A VALIDB_A VDD VDD pfet_03v3 w=5.0u l=0.28u
XK1_LANA_A_0 K1_A_A K1_SAB_A K1_LA_m_A VSS nfet_03v3 w=5.0u l=0.28u
XK1_LANB_A_0 K1_LA_m_A K1_AB_A VSS VSS nfet_03v3 w=5.0u l=0.28u
XK1_LAPA_A_0 K1_A_A K1_SAB_A VDD VDD pfet_03v3 w=5.0u l=0.28u
XK1_LAPB_A_0 K1_A_A K1_AB_A VDD VDD pfet_03v3 w=5.0u l=0.28u
XK1_LBNA_A_0 K1_AB_A K1_A_A K1_LB_m_A VSS nfet_03v3 w=5.0u l=0.28u
XK1_LBNB_A_0 K1_LB_m_A RB_A VSS VSS nfet_03v3 w=5.0u l=0.28u
XK1_LBPA_A_0 K1_AB_A K1_A_A VDD VDD pfet_03v3 w=5.0u l=0.28u
XK1_LBPB_A_0 K1_AB_A RB_A VDD VDD pfet_03v3 w=5.0u l=0.28u
XK1_SPNA_A_0 K1_SETP_A K1_AB_A VSS VSS nfet_03v3 w=2.5u l=0.28u
XK1_SPNB_A_0 K1_SETP_A D1_A VSS VSS nfet_03v3 w=2.5u l=0.28u
XK1_SPNC_A_0 K1_SETP_A DPB_A VSS VSS nfet_03v3 w=2.5u l=0.28u
XK1_SPPA_A_0 K1_SP_m1_A K1_AB_A VDD VDD pfet_03v3 w=15.0u l=0.28u
XK1_SPPB_A_0 K1_SP_m2_A D1_A K1_SP_m1_A VDD pfet_03v3 w=15.0u l=0.28u
XK1_SPPC_A_0 K1_SETP_A DPB_A K1_SP_m2_A VDD pfet_03v3 w=15.0u l=0.28u
XK1_SNNA_A_0 K1_SETN_A K1_AB_A VSS VSS nfet_03v3 w=2.5u l=0.28u
XK1_SNNB_A_0 K1_SETN_A D1_A VSS VSS nfet_03v3 w=2.5u l=0.28u
XK1_SNNC_A_0 K1_SETN_A DNB_A VSS VSS nfet_03v3 w=2.5u l=0.28u
XK1_SNPA_A_0 K1_SN_m1_A K1_AB_A VDD VDD pfet_03v3 w=15.0u l=0.28u
XK1_SNPB_A_0 K1_SN_m2_A D1_A K1_SN_m1_A VDD pfet_03v3 w=15.0u l=0.28u
XK1_SNPC_A_0 K1_SETN_A DNB_A K1_SN_m2_A VDD pfet_03v3 w=15.0u l=0.28u
XK1_PANA_A_0 K1_QP_A R_A VSS VSS nfet_03v3 w=2.5u l=0.28u
XK1_PANB_A_0 K1_QP_A K1_QPB_A VSS VSS nfet_03v3 w=2.5u l=0.28u
XK1_PAPA_A_0 K1_PA_m_A R_A VDD VDD pfet_03v3 w=10.0u l=0.28u
XK1_PAPB_A_0 K1_QP_A K1_QPB_A K1_PA_m_A VDD pfet_03v3 w=10.0u l=0.28u
XK1_PBNA_A_0 K1_QPB_A K1_SETP_A VSS VSS nfet_03v3 w=2.5u l=0.28u
XK1_PBNB_A_0 K1_QPB_A K1_QP_A VSS VSS nfet_03v3 w=2.5u l=0.28u
XK1_PBPA_A_0 K1_PB_m_A K1_SETP_A VDD VDD pfet_03v3 w=10.0u l=0.28u
XK1_PBPB_A_0 K1_QPB_A K1_QP_A K1_PB_m_A VDD pfet_03v3 w=10.0u l=0.28u
XK1_NANA_A_0 K1_QN_A R_A VSS VSS nfet_03v3 w=2.5u l=0.28u
XK1_NANB_A_0 K1_QN_A K1_QNB_A VSS VSS nfet_03v3 w=2.5u l=0.28u
XK1_NAPA_A_0 K1_NA_m_A R_A VDD VDD pfet_03v3 w=10.0u l=0.28u
XK1_NAPB_A_0 K1_QN_A K1_QNB_A K1_NA_m_A VDD pfet_03v3 w=10.0u l=0.28u
XK1_NBNA_A_0 K1_QNB_A K1_SETN_A VSS VSS nfet_03v3 w=2.5u l=0.28u
XK1_NBNB_A_0 K1_QNB_A K1_QN_A VSS VSS nfet_03v3 w=2.5u l=0.28u
XK1_NBPA_A_0 K1_NB_m_A K1_SETN_A VDD VDD pfet_03v3 w=10.0u l=0.28u
XK1_NBPB_A_0 K1_QNB_A K1_QN_A K1_NB_m_A VDD pfet_03v3 w=10.0u l=0.28u
XK1_DNA_A_0 D1_A K1_QPB_A K1_D_m_A VSS nfet_03v3 w=5.0u l=0.28u
XK1_DNB_A_0 K1_D_m_A K1_QNB_A VSS VSS nfet_03v3 w=5.0u l=0.28u
XK1_DPA_A_0 D1_A K1_QPB_A VDD VDD pfet_03v3 w=5.0u l=0.28u
XK1_DPB_A_0 D1_A K1_QNB_A VDD VDD pfet_03v3 w=5.0u l=0.28u
XDRP7NA_A_0 RP7_A K1_QP_A VSS VSS nfet_03v3 w=2.5u l=0.28u
XDRP7NB_A_0 RP7_A FP_A VSS VSS nfet_03v3 w=2.5u l=0.28u
XDRP7PA_A_0 DRP7_m_A K1_QP_A VDD VDD pfet_03v3 w=10.0u l=0.28u
XDRP7PB_A_0 RP7_A FP_A DRP7_m_A VDD pfet_03v3 w=10.0u l=0.28u
XDGP7N_A_0 GP7_A RP7_A VSS VSS nfet_03v3 w=2.5u l=0.28u
XDGP7P_A_0 GP7_A RP7_A VDD VDD pfet_03v3 w=5.0u l=0.28u
XDRN7NA_A_0 RN7_A K1_QN_A VSS VSS nfet_03v3 w=2.5u l=0.28u
XDRN7NB_A_0 RN7_A FN_A VSS VSS nfet_03v3 w=2.5u l=0.28u
XDRN7PA_A_0 DRN7_m_A K1_QN_A VDD VDD pfet_03v3 w=10.0u l=0.28u
XDRN7PB_A_0 RN7_A FN_A DRN7_m_A VDD pfet_03v3 w=10.0u l=0.28u
XDGN7N_A_0 GN7_A RN7_A VSS VSS nfet_03v3 w=2.5u l=0.28u
XDGN7P_A_0 GN7_A RN7_A VDD VDD pfet_03v3 w=5.0u l=0.28u
XK2_SNA_A_0 K2_SAB_A D1_A K2_S_m_A VSS nfet_03v3 w=5.0u l=0.28u
XK2_SNB_A_0 K2_S_m_A VALIDB_A VSS VSS nfet_03v3 w=5.0u l=0.28u
XK2_SPA_A_0 K2_SAB_A D1_A VDD VDD pfet_03v3 w=5.0u l=0.28u
XK2_SPB_A_0 K2_SAB_A VALIDB_A VDD VDD pfet_03v3 w=5.0u l=0.28u
XK2_LANA_A_0 K2_A_A K2_SAB_A K2_LA_m_A VSS nfet_03v3 w=5.0u l=0.28u
XK2_LANB_A_0 K2_LA_m_A K2_AB_A VSS VSS nfet_03v3 w=5.0u l=0.28u
XK2_LAPA_A_0 K2_A_A K2_SAB_A VDD VDD pfet_03v3 w=5.0u l=0.28u
XK2_LAPB_A_0 K2_A_A K2_AB_A VDD VDD pfet_03v3 w=5.0u l=0.28u
XK2_LBNA_A_0 K2_AB_A K2_A_A K2_LB_m_A VSS nfet_03v3 w=5.0u l=0.28u
XK2_LBNB_A_0 K2_LB_m_A RB_A VSS VSS nfet_03v3 w=5.0u l=0.28u
XK2_LBPA_A_0 K2_AB_A K2_A_A VDD VDD pfet_03v3 w=5.0u l=0.28u
XK2_LBPB_A_0 K2_AB_A RB_A VDD VDD pfet_03v3 w=5.0u l=0.28u
XK2_SPNA_A_0 K2_SETP_A K2_AB_A VSS VSS nfet_03v3 w=2.5u l=0.28u
XK2_SPNB_A_0 K2_SETP_A D2_A VSS VSS nfet_03v3 w=2.5u l=0.28u
XK2_SPNC_A_0 K2_SETP_A DPB_A VSS VSS nfet_03v3 w=2.5u l=0.28u
XK2_SPPA_A_0 K2_SP_m1_A K2_AB_A VDD VDD pfet_03v3 w=15.0u l=0.28u
XK2_SPPB_A_0 K2_SP_m2_A D2_A K2_SP_m1_A VDD pfet_03v3 w=15.0u l=0.28u
XK2_SPPC_A_0 K2_SETP_A DPB_A K2_SP_m2_A VDD pfet_03v3 w=15.0u l=0.28u
XK2_SNNA_A_0 K2_SETN_A K2_AB_A VSS VSS nfet_03v3 w=2.5u l=0.28u
XK2_SNNB_A_0 K2_SETN_A D2_A VSS VSS nfet_03v3 w=2.5u l=0.28u
XK2_SNNC_A_0 K2_SETN_A DNB_A VSS VSS nfet_03v3 w=2.5u l=0.28u
XK2_SNPA_A_0 K2_SN_m1_A K2_AB_A VDD VDD pfet_03v3 w=15.0u l=0.28u
XK2_SNPB_A_0 K2_SN_m2_A D2_A K2_SN_m1_A VDD pfet_03v3 w=15.0u l=0.28u
XK2_SNPC_A_0 K2_SETN_A DNB_A K2_SN_m2_A VDD pfet_03v3 w=15.0u l=0.28u
XK2_PANA_A_0 K2_QP_A R_A VSS VSS nfet_03v3 w=2.5u l=0.28u
XK2_PANB_A_0 K2_QP_A K2_QPB_A VSS VSS nfet_03v3 w=2.5u l=0.28u
XK2_PAPA_A_0 K2_PA_m_A R_A VDD VDD pfet_03v3 w=10.0u l=0.28u
XK2_PAPB_A_0 K2_QP_A K2_QPB_A K2_PA_m_A VDD pfet_03v3 w=10.0u l=0.28u
XK2_PBNA_A_0 K2_QPB_A K2_SETP_A VSS VSS nfet_03v3 w=2.5u l=0.28u
XK2_PBNB_A_0 K2_QPB_A K2_QP_A VSS VSS nfet_03v3 w=2.5u l=0.28u
XK2_PBPA_A_0 K2_PB_m_A K2_SETP_A VDD VDD pfet_03v3 w=10.0u l=0.28u
XK2_PBPB_A_0 K2_QPB_A K2_QP_A K2_PB_m_A VDD pfet_03v3 w=10.0u l=0.28u
XK2_NANA_A_0 K2_QN_A R_A VSS VSS nfet_03v3 w=2.5u l=0.28u
XK2_NANB_A_0 K2_QN_A K2_QNB_A VSS VSS nfet_03v3 w=2.5u l=0.28u
XK2_NAPA_A_0 K2_NA_m_A R_A VDD VDD pfet_03v3 w=10.0u l=0.28u
XK2_NAPB_A_0 K2_QN_A K2_QNB_A K2_NA_m_A VDD pfet_03v3 w=10.0u l=0.28u
XK2_NBNA_A_0 K2_QNB_A K2_SETN_A VSS VSS nfet_03v3 w=2.5u l=0.28u
XK2_NBNB_A_0 K2_QNB_A K2_QN_A VSS VSS nfet_03v3 w=2.5u l=0.28u
XK2_NBPA_A_0 K2_NB_m_A K2_SETN_A VDD VDD pfet_03v3 w=10.0u l=0.28u
XK2_NBPB_A_0 K2_QNB_A K2_QN_A K2_NB_m_A VDD pfet_03v3 w=10.0u l=0.28u
XK2_DNA_A_0 D2_A K2_QPB_A K2_D_m_A VSS nfet_03v3 w=5.0u l=0.28u
XK2_DNB_A_0 K2_D_m_A K2_QNB_A VSS VSS nfet_03v3 w=5.0u l=0.28u
XK2_DPA_A_0 D2_A K2_QPB_A VDD VDD pfet_03v3 w=5.0u l=0.28u
XK2_DPB_A_0 D2_A K2_QNB_A VDD VDD pfet_03v3 w=5.0u l=0.28u
XDGP6N_A_0 GP6_A K2_QPB_A VSS VSS nfet_03v3 w=2.5u l=0.28u
XDGP6P_A_0 GP6_A K2_QPB_A VDD VDD pfet_03v3 w=5.0u l=0.28u
XDRP6N_A_0 RP6_A K2_QP_A VSS VSS nfet_03v3 w=2.5u l=0.28u
XDRP6P_A_0 RP6_A K2_QP_A VDD VDD pfet_03v3 w=5.0u l=0.28u
XDGN6N_A_0 GN6_A K2_QNB_A VSS VSS nfet_03v3 w=2.5u l=0.28u
XDGN6P_A_0 GN6_A K2_QNB_A VDD VDD pfet_03v3 w=5.0u l=0.28u
XDRN6N_A_0 RN6_A K2_QN_A VSS VSS nfet_03v3 w=2.5u l=0.28u
XDRN6P_A_0 RN6_A K2_QN_A VDD VDD pfet_03v3 w=5.0u l=0.28u
XK3_SNA_A_0 K3_SAB_A D2_A K3_S_m_A VSS nfet_03v3 w=5.0u l=0.28u
XK3_SNB_A_0 K3_S_m_A VALIDB_A VSS VSS nfet_03v3 w=5.0u l=0.28u
XK3_SPA_A_0 K3_SAB_A D2_A VDD VDD pfet_03v3 w=5.0u l=0.28u
XK3_SPB_A_0 K3_SAB_A VALIDB_A VDD VDD pfet_03v3 w=5.0u l=0.28u
XK3_LANA_A_0 K3_A_A K3_SAB_A K3_LA_m_A VSS nfet_03v3 w=5.0u l=0.28u
XK3_LANB_A_0 K3_LA_m_A K3_AB_A VSS VSS nfet_03v3 w=5.0u l=0.28u
XK3_LAPA_A_0 K3_A_A K3_SAB_A VDD VDD pfet_03v3 w=5.0u l=0.28u
XK3_LAPB_A_0 K3_A_A K3_AB_A VDD VDD pfet_03v3 w=5.0u l=0.28u
XK3_LBNA_A_0 K3_AB_A K3_A_A K3_LB_m_A VSS nfet_03v3 w=5.0u l=0.28u
XK3_LBNB_A_0 K3_LB_m_A RB_A VSS VSS nfet_03v3 w=5.0u l=0.28u
XK3_LBPA_A_0 K3_AB_A K3_A_A VDD VDD pfet_03v3 w=5.0u l=0.28u
XK3_LBPB_A_0 K3_AB_A RB_A VDD VDD pfet_03v3 w=5.0u l=0.28u
XK3_SPNA_A_0 K3_SETP_A K3_AB_A VSS VSS nfet_03v3 w=2.5u l=0.28u
XK3_SPNB_A_0 K3_SETP_A D3_A VSS VSS nfet_03v3 w=2.5u l=0.28u
XK3_SPNC_A_0 K3_SETP_A DPB_A VSS VSS nfet_03v3 w=2.5u l=0.28u
XK3_SPPA_A_0 K3_SP_m1_A K3_AB_A VDD VDD pfet_03v3 w=15.0u l=0.28u
XK3_SPPB_A_0 K3_SP_m2_A D3_A K3_SP_m1_A VDD pfet_03v3 w=15.0u l=0.28u
XK3_SPPC_A_0 K3_SETP_A DPB_A K3_SP_m2_A VDD pfet_03v3 w=15.0u l=0.28u
XK3_SNNA_A_0 K3_SETN_A K3_AB_A VSS VSS nfet_03v3 w=2.5u l=0.28u
XK3_SNNB_A_0 K3_SETN_A D3_A VSS VSS nfet_03v3 w=2.5u l=0.28u
XK3_SNNC_A_0 K3_SETN_A DNB_A VSS VSS nfet_03v3 w=2.5u l=0.28u
XK3_SNPA_A_0 K3_SN_m1_A K3_AB_A VDD VDD pfet_03v3 w=15.0u l=0.28u
XK3_SNPB_A_0 K3_SN_m2_A D3_A K3_SN_m1_A VDD pfet_03v3 w=15.0u l=0.28u
XK3_SNPC_A_0 K3_SETN_A DNB_A K3_SN_m2_A VDD pfet_03v3 w=15.0u l=0.28u
XK3_PANA_A_0 K3_QP_A R_A VSS VSS nfet_03v3 w=2.5u l=0.28u
XK3_PANB_A_0 K3_QP_A K3_QPB_A VSS VSS nfet_03v3 w=2.5u l=0.28u
XK3_PAPA_A_0 K3_PA_m_A R_A VDD VDD pfet_03v3 w=10.0u l=0.28u
XK3_PAPB_A_0 K3_QP_A K3_QPB_A K3_PA_m_A VDD pfet_03v3 w=10.0u l=0.28u
XK3_PBNA_A_0 K3_QPB_A K3_SETP_A VSS VSS nfet_03v3 w=2.5u l=0.28u
XK3_PBNB_A_0 K3_QPB_A K3_QP_A VSS VSS nfet_03v3 w=2.5u l=0.28u
XK3_PBPA_A_0 K3_PB_m_A K3_SETP_A VDD VDD pfet_03v3 w=10.0u l=0.28u
XK3_PBPB_A_0 K3_QPB_A K3_QP_A K3_PB_m_A VDD pfet_03v3 w=10.0u l=0.28u
XK3_NANA_A_0 K3_QN_A R_A VSS VSS nfet_03v3 w=2.5u l=0.28u
XK3_NANB_A_0 K3_QN_A K3_QNB_A VSS VSS nfet_03v3 w=2.5u l=0.28u
XK3_NAPA_A_0 K3_NA_m_A R_A VDD VDD pfet_03v3 w=10.0u l=0.28u
XK3_NAPB_A_0 K3_QN_A K3_QNB_A K3_NA_m_A VDD pfet_03v3 w=10.0u l=0.28u
XK3_NBNA_A_0 K3_QNB_A K3_SETN_A VSS VSS nfet_03v3 w=2.5u l=0.28u
XK3_NBNB_A_0 K3_QNB_A K3_QN_A VSS VSS nfet_03v3 w=2.5u l=0.28u
XK3_NBPA_A_0 K3_NB_m_A K3_SETN_A VDD VDD pfet_03v3 w=10.0u l=0.28u
XK3_NBPB_A_0 K3_QNB_A K3_QN_A K3_NB_m_A VDD pfet_03v3 w=10.0u l=0.28u
XK3_DNA_A_0 D3_A K3_QPB_A K3_D_m_A VSS nfet_03v3 w=5.0u l=0.28u
XK3_DNB_A_0 K3_D_m_A K3_QNB_A VSS VSS nfet_03v3 w=5.0u l=0.28u
XK3_DPA_A_0 D3_A K3_QPB_A VDD VDD pfet_03v3 w=5.0u l=0.28u
XK3_DPB_A_0 D3_A K3_QNB_A VDD VDD pfet_03v3 w=5.0u l=0.28u
XDGP5N_A_0 GP5_A K3_QPB_A VSS VSS nfet_03v3 w=5.0u l=0.28u
XDGP5P_A_0 GP5_A K3_QPB_A VDD VDD pfet_03v3 w=10.0u l=0.28u
XDRP5N_A_0 RP5_A K3_QP_A VSS VSS nfet_03v3 w=5.0u l=0.28u
XDRP5P_A_0 RP5_A K3_QP_A VDD VDD pfet_03v3 w=10.0u l=0.28u
XDGN5N_A_0 GN5_A K3_QNB_A VSS VSS nfet_03v3 w=5.0u l=0.28u
XDGN5P_A_0 GN5_A K3_QNB_A VDD VDD pfet_03v3 w=10.0u l=0.28u
XDRN5N_A_0 RN5_A K3_QN_A VSS VSS nfet_03v3 w=5.0u l=0.28u
XDRN5P_A_0 RN5_A K3_QN_A VDD VDD pfet_03v3 w=10.0u l=0.28u
XK4_SNA_A_0 K4_SAB_A D3_A K4_S_m_A VSS nfet_03v3 w=5.0u l=0.28u
XK4_SNB_A_0 K4_S_m_A VALIDB_A VSS VSS nfet_03v3 w=5.0u l=0.28u
XK4_SPA_A_0 K4_SAB_A D3_A VDD VDD pfet_03v3 w=5.0u l=0.28u
XK4_SPB_A_0 K4_SAB_A VALIDB_A VDD VDD pfet_03v3 w=5.0u l=0.28u
XK4_LANA_A_0 K4_A_A K4_SAB_A K4_LA_m_A VSS nfet_03v3 w=5.0u l=0.28u
XK4_LANB_A_0 K4_LA_m_A K4_AB_A VSS VSS nfet_03v3 w=5.0u l=0.28u
XK4_LAPA_A_0 K4_A_A K4_SAB_A VDD VDD pfet_03v3 w=5.0u l=0.28u
XK4_LAPB_A_0 K4_A_A K4_AB_A VDD VDD pfet_03v3 w=5.0u l=0.28u
XK4_LBNA_A_0 K4_AB_A K4_A_A K4_LB_m_A VSS nfet_03v3 w=5.0u l=0.28u
XK4_LBNB_A_0 K4_LB_m_A RB_A VSS VSS nfet_03v3 w=5.0u l=0.28u
XK4_LBPA_A_0 K4_AB_A K4_A_A VDD VDD pfet_03v3 w=5.0u l=0.28u
XK4_LBPB_A_0 K4_AB_A RB_A VDD VDD pfet_03v3 w=5.0u l=0.28u
XK4_SPNA_A_0 K4_SETP_A K4_AB_A VSS VSS nfet_03v3 w=2.5u l=0.28u
XK4_SPNB_A_0 K4_SETP_A D4_A VSS VSS nfet_03v3 w=2.5u l=0.28u
XK4_SPNC_A_0 K4_SETP_A DPB_A VSS VSS nfet_03v3 w=2.5u l=0.28u
XK4_SPPA_A_0 K4_SP_m1_A K4_AB_A VDD VDD pfet_03v3 w=15.0u l=0.28u
XK4_SPPB_A_0 K4_SP_m2_A D4_A K4_SP_m1_A VDD pfet_03v3 w=15.0u l=0.28u
XK4_SPPC_A_0 K4_SETP_A DPB_A K4_SP_m2_A VDD pfet_03v3 w=15.0u l=0.28u
XK4_SNNA_A_0 K4_SETN_A K4_AB_A VSS VSS nfet_03v3 w=2.5u l=0.28u
XK4_SNNB_A_0 K4_SETN_A D4_A VSS VSS nfet_03v3 w=2.5u l=0.28u
XK4_SNNC_A_0 K4_SETN_A DNB_A VSS VSS nfet_03v3 w=2.5u l=0.28u
XK4_SNPA_A_0 K4_SN_m1_A K4_AB_A VDD VDD pfet_03v3 w=15.0u l=0.28u
XK4_SNPB_A_0 K4_SN_m2_A D4_A K4_SN_m1_A VDD pfet_03v3 w=15.0u l=0.28u
XK4_SNPC_A_0 K4_SETN_A DNB_A K4_SN_m2_A VDD pfet_03v3 w=15.0u l=0.28u
XK4_PANA_A_0 K4_QP_A R_A VSS VSS nfet_03v3 w=2.5u l=0.28u
XK4_PANB_A_0 K4_QP_A K4_QPB_A VSS VSS nfet_03v3 w=2.5u l=0.28u
XK4_PAPA_A_0 K4_PA_m_A R_A VDD VDD pfet_03v3 w=10.0u l=0.28u
XK4_PAPB_A_0 K4_QP_A K4_QPB_A K4_PA_m_A VDD pfet_03v3 w=10.0u l=0.28u
XK4_PBNA_A_0 K4_QPB_A K4_SETP_A VSS VSS nfet_03v3 w=2.5u l=0.28u
XK4_PBNB_A_0 K4_QPB_A K4_QP_A VSS VSS nfet_03v3 w=2.5u l=0.28u
XK4_PBPA_A_0 K4_PB_m_A K4_SETP_A VDD VDD pfet_03v3 w=10.0u l=0.28u
XK4_PBPB_A_0 K4_QPB_A K4_QP_A K4_PB_m_A VDD pfet_03v3 w=10.0u l=0.28u
XK4_NANA_A_0 K4_QN_A R_A VSS VSS nfet_03v3 w=2.5u l=0.28u
XK4_NANB_A_0 K4_QN_A K4_QNB_A VSS VSS nfet_03v3 w=2.5u l=0.28u
XK4_NAPA_A_0 K4_NA_m_A R_A VDD VDD pfet_03v3 w=10.0u l=0.28u
XK4_NAPB_A_0 K4_QN_A K4_QNB_A K4_NA_m_A VDD pfet_03v3 w=10.0u l=0.28u
XK4_NBNA_A_0 K4_QNB_A K4_SETN_A VSS VSS nfet_03v3 w=2.5u l=0.28u
XK4_NBNB_A_0 K4_QNB_A K4_QN_A VSS VSS nfet_03v3 w=2.5u l=0.28u
XK4_NBPA_A_0 K4_NB_m_A K4_SETN_A VDD VDD pfet_03v3 w=10.0u l=0.28u
XK4_NBPB_A_0 K4_QNB_A K4_QN_A K4_NB_m_A VDD pfet_03v3 w=10.0u l=0.28u
XK4_DNA_A_0 D4_A K4_QPB_A K4_D_m_A VSS nfet_03v3 w=5.0u l=0.28u
XK4_DNB_A_0 K4_D_m_A K4_QNB_A VSS VSS nfet_03v3 w=5.0u l=0.28u
XK4_DPA_A_0 D4_A K4_QPB_A VDD VDD pfet_03v3 w=5.0u l=0.28u
XK4_DPB_A_0 D4_A K4_QNB_A VDD VDD pfet_03v3 w=5.0u l=0.28u
XDGP4N_A_0 GP4_A K4_QPB_A VSS VSS nfet_03v3 w=5.0u l=0.28u
XDGP4P_A_0 GP4_A K4_QPB_A VDD VDD pfet_03v3 w=10.0u l=0.28u
XDRP4N_A_0 RP4_A K4_QP_A VSS VSS nfet_03v3 w=5.0u l=0.28u
XDRP4P_A_0 RP4_A K4_QP_A VDD VDD pfet_03v3 w=10.0u l=0.28u
XDGN4N_A_0 GN4_A K4_QNB_A VSS VSS nfet_03v3 w=5.0u l=0.28u
XDGN4P_A_0 GN4_A K4_QNB_A VDD VDD pfet_03v3 w=10.0u l=0.28u
XDRN4N_A_0 RN4_A K4_QN_A VSS VSS nfet_03v3 w=5.0u l=0.28u
XDRN4P_A_0 RN4_A K4_QN_A VDD VDD pfet_03v3 w=10.0u l=0.28u
XK5_SNA_A_0 K5_SAB_A D4_A K5_S_m_A VSS nfet_03v3 w=5.0u l=0.28u
XK5_SNB_A_0 K5_S_m_A VALIDB_A VSS VSS nfet_03v3 w=5.0u l=0.28u
XK5_SPA_A_0 K5_SAB_A D4_A VDD VDD pfet_03v3 w=5.0u l=0.28u
XK5_SPB_A_0 K5_SAB_A VALIDB_A VDD VDD pfet_03v3 w=5.0u l=0.28u
XK5_LANA_A_0 K5_A_A K5_SAB_A K5_LA_m_A VSS nfet_03v3 w=5.0u l=0.28u
XK5_LANB_A_0 K5_LA_m_A K5_AB_A VSS VSS nfet_03v3 w=5.0u l=0.28u
XK5_LAPA_A_0 K5_A_A K5_SAB_A VDD VDD pfet_03v3 w=5.0u l=0.28u
XK5_LAPB_A_0 K5_A_A K5_AB_A VDD VDD pfet_03v3 w=5.0u l=0.28u
XK5_LBNA_A_0 K5_AB_A K5_A_A K5_LB_m_A VSS nfet_03v3 w=5.0u l=0.28u
XK5_LBNB_A_0 K5_LB_m_A RB_A VSS VSS nfet_03v3 w=5.0u l=0.28u
XK5_LBPA_A_0 K5_AB_A K5_A_A VDD VDD pfet_03v3 w=5.0u l=0.28u
XK5_LBPB_A_0 K5_AB_A RB_A VDD VDD pfet_03v3 w=5.0u l=0.28u
XK5_SPNA_A_0 K5_SETP_A K5_AB_A VSS VSS nfet_03v3 w=2.5u l=0.28u
XK5_SPNB_A_0 K5_SETP_A D5_A VSS VSS nfet_03v3 w=2.5u l=0.28u
XK5_SPNC_A_0 K5_SETP_A DPB_A VSS VSS nfet_03v3 w=2.5u l=0.28u
XK5_SPPA_A_0 K5_SP_m1_A K5_AB_A VDD VDD pfet_03v3 w=15.0u l=0.28u
XK5_SPPB_A_0 K5_SP_m2_A D5_A K5_SP_m1_A VDD pfet_03v3 w=15.0u l=0.28u
XK5_SPPC_A_0 K5_SETP_A DPB_A K5_SP_m2_A VDD pfet_03v3 w=15.0u l=0.28u
XK5_SNNA_A_0 K5_SETN_A K5_AB_A VSS VSS nfet_03v3 w=2.5u l=0.28u
XK5_SNNB_A_0 K5_SETN_A D5_A VSS VSS nfet_03v3 w=2.5u l=0.28u
XK5_SNNC_A_0 K5_SETN_A DNB_A VSS VSS nfet_03v3 w=2.5u l=0.28u
XK5_SNPA_A_0 K5_SN_m1_A K5_AB_A VDD VDD pfet_03v3 w=15.0u l=0.28u
XK5_SNPB_A_0 K5_SN_m2_A D5_A K5_SN_m1_A VDD pfet_03v3 w=15.0u l=0.28u
XK5_SNPC_A_0 K5_SETN_A DNB_A K5_SN_m2_A VDD pfet_03v3 w=15.0u l=0.28u
XK5_PANA_A_0 K5_QP_A R_A VSS VSS nfet_03v3 w=2.5u l=0.28u
XK5_PANB_A_0 K5_QP_A K5_QPB_A VSS VSS nfet_03v3 w=2.5u l=0.28u
XK5_PAPA_A_0 K5_PA_m_A R_A VDD VDD pfet_03v3 w=10.0u l=0.28u
XK5_PAPB_A_0 K5_QP_A K5_QPB_A K5_PA_m_A VDD pfet_03v3 w=10.0u l=0.28u
XK5_PBNA_A_0 K5_QPB_A K5_SETP_A VSS VSS nfet_03v3 w=2.5u l=0.28u
XK5_PBNB_A_0 K5_QPB_A K5_QP_A VSS VSS nfet_03v3 w=2.5u l=0.28u
XK5_PBPA_A_0 K5_PB_m_A K5_SETP_A VDD VDD pfet_03v3 w=10.0u l=0.28u
XK5_PBPB_A_0 K5_QPB_A K5_QP_A K5_PB_m_A VDD pfet_03v3 w=10.0u l=0.28u
XK5_NANA_A_0 K5_QN_A R_A VSS VSS nfet_03v3 w=2.5u l=0.28u
XK5_NANB_A_0 K5_QN_A K5_QNB_A VSS VSS nfet_03v3 w=2.5u l=0.28u
XK5_NAPA_A_0 K5_NA_m_A R_A VDD VDD pfet_03v3 w=10.0u l=0.28u
XK5_NAPB_A_0 K5_QN_A K5_QNB_A K5_NA_m_A VDD pfet_03v3 w=10.0u l=0.28u
XK5_NBNA_A_0 K5_QNB_A K5_SETN_A VSS VSS nfet_03v3 w=2.5u l=0.28u
XK5_NBNB_A_0 K5_QNB_A K5_QN_A VSS VSS nfet_03v3 w=2.5u l=0.28u
XK5_NBPA_A_0 K5_NB_m_A K5_SETN_A VDD VDD pfet_03v3 w=10.0u l=0.28u
XK5_NBPB_A_0 K5_QNB_A K5_QN_A K5_NB_m_A VDD pfet_03v3 w=10.0u l=0.28u
XK5_DNA_A_0 D5_A K5_QPB_A K5_D_m_A VSS nfet_03v3 w=5.0u l=0.28u
XK5_DNB_A_0 K5_D_m_A K5_QNB_A VSS VSS nfet_03v3 w=5.0u l=0.28u
XK5_DPA_A_0 D5_A K5_QPB_A VDD VDD pfet_03v3 w=5.0u l=0.28u
XK5_DPB_A_0 D5_A K5_QNB_A VDD VDD pfet_03v3 w=5.0u l=0.28u
XDGP3N_A_0 GP3_A K5_QPB_A VSS VSS nfet_03v3 w=2.5u l=0.28u
XDGP3P_A_0 GP3_A K5_QPB_A VDD VDD pfet_03v3 w=5.0u l=0.28u
XDRP3N_A_0 RP3_A K5_QP_A VSS VSS nfet_03v3 w=2.5u l=0.28u
XDRP3P_A_0 RP3_A K5_QP_A VDD VDD pfet_03v3 w=5.0u l=0.28u
XDGN3N_A_0 GN3_A K5_QNB_A VSS VSS nfet_03v3 w=2.5u l=0.28u
XDGN3P_A_0 GN3_A K5_QNB_A VDD VDD pfet_03v3 w=5.0u l=0.28u
XDRN3N_A_0 RN3_A K5_QN_A VSS VSS nfet_03v3 w=2.5u l=0.28u
XDRN3P_A_0 RN3_A K5_QN_A VDD VDD pfet_03v3 w=5.0u l=0.28u
XK6_SNA_A_0 K6_SAB_A D5_A K6_S_m_A VSS nfet_03v3 w=5.0u l=0.28u
XK6_SNB_A_0 K6_S_m_A VALIDB_A VSS VSS nfet_03v3 w=5.0u l=0.28u
XK6_SPA_A_0 K6_SAB_A D5_A VDD VDD pfet_03v3 w=5.0u l=0.28u
XK6_SPB_A_0 K6_SAB_A VALIDB_A VDD VDD pfet_03v3 w=5.0u l=0.28u
XK6_LANA_A_0 K6_A_A K6_SAB_A K6_LA_m_A VSS nfet_03v3 w=5.0u l=0.28u
XK6_LANB_A_0 K6_LA_m_A K6_AB_A VSS VSS nfet_03v3 w=5.0u l=0.28u
XK6_LAPA_A_0 K6_A_A K6_SAB_A VDD VDD pfet_03v3 w=5.0u l=0.28u
XK6_LAPB_A_0 K6_A_A K6_AB_A VDD VDD pfet_03v3 w=5.0u l=0.28u
XK6_LBNA_A_0 K6_AB_A K6_A_A K6_LB_m_A VSS nfet_03v3 w=5.0u l=0.28u
XK6_LBNB_A_0 K6_LB_m_A RB_A VSS VSS nfet_03v3 w=5.0u l=0.28u
XK6_LBPA_A_0 K6_AB_A K6_A_A VDD VDD pfet_03v3 w=5.0u l=0.28u
XK6_LBPB_A_0 K6_AB_A RB_A VDD VDD pfet_03v3 w=5.0u l=0.28u
XK6_SPNA_A_0 K6_SETP_A K6_AB_A VSS VSS nfet_03v3 w=2.5u l=0.28u
XK6_SPNB_A_0 K6_SETP_A D6_A VSS VSS nfet_03v3 w=2.5u l=0.28u
XK6_SPNC_A_0 K6_SETP_A DPB_A VSS VSS nfet_03v3 w=2.5u l=0.28u
XK6_SPPA_A_0 K6_SP_m1_A K6_AB_A VDD VDD pfet_03v3 w=15.0u l=0.28u
XK6_SPPB_A_0 K6_SP_m2_A D6_A K6_SP_m1_A VDD pfet_03v3 w=15.0u l=0.28u
XK6_SPPC_A_0 K6_SETP_A DPB_A K6_SP_m2_A VDD pfet_03v3 w=15.0u l=0.28u
XK6_SNNA_A_0 K6_SETN_A K6_AB_A VSS VSS nfet_03v3 w=2.5u l=0.28u
XK6_SNNB_A_0 K6_SETN_A D6_A VSS VSS nfet_03v3 w=2.5u l=0.28u
XK6_SNNC_A_0 K6_SETN_A DNB_A VSS VSS nfet_03v3 w=2.5u l=0.28u
XK6_SNPA_A_0 K6_SN_m1_A K6_AB_A VDD VDD pfet_03v3 w=15.0u l=0.28u
XK6_SNPB_A_0 K6_SN_m2_A D6_A K6_SN_m1_A VDD pfet_03v3 w=15.0u l=0.28u
XK6_SNPC_A_0 K6_SETN_A DNB_A K6_SN_m2_A VDD pfet_03v3 w=15.0u l=0.28u
XK6_PANA_A_0 K6_QP_A R_A VSS VSS nfet_03v3 w=2.5u l=0.28u
XK6_PANB_A_0 K6_QP_A K6_QPB_A VSS VSS nfet_03v3 w=2.5u l=0.28u
XK6_PAPA_A_0 K6_PA_m_A R_A VDD VDD pfet_03v3 w=10.0u l=0.28u
XK6_PAPB_A_0 K6_QP_A K6_QPB_A K6_PA_m_A VDD pfet_03v3 w=10.0u l=0.28u
XK6_PBNA_A_0 K6_QPB_A K6_SETP_A VSS VSS nfet_03v3 w=2.5u l=0.28u
XK6_PBNB_A_0 K6_QPB_A K6_QP_A VSS VSS nfet_03v3 w=2.5u l=0.28u
XK6_PBPA_A_0 K6_PB_m_A K6_SETP_A VDD VDD pfet_03v3 w=10.0u l=0.28u
XK6_PBPB_A_0 K6_QPB_A K6_QP_A K6_PB_m_A VDD pfet_03v3 w=10.0u l=0.28u
XK6_NANA_A_0 K6_QN_A R_A VSS VSS nfet_03v3 w=2.5u l=0.28u
XK6_NANB_A_0 K6_QN_A K6_QNB_A VSS VSS nfet_03v3 w=2.5u l=0.28u
XK6_NAPA_A_0 K6_NA_m_A R_A VDD VDD pfet_03v3 w=10.0u l=0.28u
XK6_NAPB_A_0 K6_QN_A K6_QNB_A K6_NA_m_A VDD pfet_03v3 w=10.0u l=0.28u
XK6_NBNA_A_0 K6_QNB_A K6_SETN_A VSS VSS nfet_03v3 w=2.5u l=0.28u
XK6_NBNB_A_0 K6_QNB_A K6_QN_A VSS VSS nfet_03v3 w=2.5u l=0.28u
XK6_NBPA_A_0 K6_NB_m_A K6_SETN_A VDD VDD pfet_03v3 w=10.0u l=0.28u
XK6_NBPB_A_0 K6_QNB_A K6_QN_A K6_NB_m_A VDD pfet_03v3 w=10.0u l=0.28u
XK6_DNA_A_0 D6_A K6_QPB_A K6_D_m_A VSS nfet_03v3 w=5.0u l=0.28u
XK6_DNB_A_0 K6_D_m_A K6_QNB_A VSS VSS nfet_03v3 w=5.0u l=0.28u
XK6_DPA_A_0 D6_A K6_QPB_A VDD VDD pfet_03v3 w=5.0u l=0.28u
XK6_DPB_A_0 D6_A K6_QNB_A VDD VDD pfet_03v3 w=5.0u l=0.28u
XDGP2N_A_0 GP2_A K6_QPB_A VSS VSS nfet_03v3 w=2.5u l=0.28u
XDGP2P_A_0 GP2_A K6_QPB_A VDD VDD pfet_03v3 w=5.0u l=0.28u
XDRP2N_A_0 RP2_A K6_QP_A VSS VSS nfet_03v3 w=2.5u l=0.28u
XDRP2P_A_0 RP2_A K6_QP_A VDD VDD pfet_03v3 w=5.0u l=0.28u
XDGN2N_A_0 GN2_A K6_QNB_A VSS VSS nfet_03v3 w=2.5u l=0.28u
XDGN2P_A_0 GN2_A K6_QNB_A VDD VDD pfet_03v3 w=5.0u l=0.28u
XDRN2N_A_0 RN2_A K6_QN_A VSS VSS nfet_03v3 w=2.5u l=0.28u
XDRN2P_A_0 RN2_A K6_QN_A VDD VDD pfet_03v3 w=5.0u l=0.28u
XK7_SNA_A_0 K7_SAB_A D6_A K7_S_m_A VSS nfet_03v3 w=5.0u l=0.28u
XK7_SNB_A_0 K7_S_m_A VALIDB_A VSS VSS nfet_03v3 w=5.0u l=0.28u
XK7_SPA_A_0 K7_SAB_A D6_A VDD VDD pfet_03v3 w=5.0u l=0.28u
XK7_SPB_A_0 K7_SAB_A VALIDB_A VDD VDD pfet_03v3 w=5.0u l=0.28u
XK7_LANA_A_0 K7_A_A K7_SAB_A K7_LA_m_A VSS nfet_03v3 w=5.0u l=0.28u
XK7_LANB_A_0 K7_LA_m_A K7_AB_A VSS VSS nfet_03v3 w=5.0u l=0.28u
XK7_LAPA_A_0 K7_A_A K7_SAB_A VDD VDD pfet_03v3 w=5.0u l=0.28u
XK7_LAPB_A_0 K7_A_A K7_AB_A VDD VDD pfet_03v3 w=5.0u l=0.28u
XK7_LBNA_A_0 K7_AB_A K7_A_A K7_LB_m_A VSS nfet_03v3 w=5.0u l=0.28u
XK7_LBNB_A_0 K7_LB_m_A RB_A VSS VSS nfet_03v3 w=5.0u l=0.28u
XK7_LBPA_A_0 K7_AB_A K7_A_A VDD VDD pfet_03v3 w=5.0u l=0.28u
XK7_LBPB_A_0 K7_AB_A RB_A VDD VDD pfet_03v3 w=5.0u l=0.28u
XK7_SPNA_A_0 K7_SETP_A K7_AB_A VSS VSS nfet_03v3 w=2.5u l=0.28u
XK7_SPNB_A_0 K7_SETP_A D7_A VSS VSS nfet_03v3 w=2.5u l=0.28u
XK7_SPNC_A_0 K7_SETP_A DPB_A VSS VSS nfet_03v3 w=2.5u l=0.28u
XK7_SPPA_A_0 K7_SP_m1_A K7_AB_A VDD VDD pfet_03v3 w=15.0u l=0.28u
XK7_SPPB_A_0 K7_SP_m2_A D7_A K7_SP_m1_A VDD pfet_03v3 w=15.0u l=0.28u
XK7_SPPC_A_0 K7_SETP_A DPB_A K7_SP_m2_A VDD pfet_03v3 w=15.0u l=0.28u
XK7_SNNA_A_0 K7_SETN_A K7_AB_A VSS VSS nfet_03v3 w=2.5u l=0.28u
XK7_SNNB_A_0 K7_SETN_A D7_A VSS VSS nfet_03v3 w=2.5u l=0.28u
XK7_SNNC_A_0 K7_SETN_A DNB_A VSS VSS nfet_03v3 w=2.5u l=0.28u
XK7_SNPA_A_0 K7_SN_m1_A K7_AB_A VDD VDD pfet_03v3 w=15.0u l=0.28u
XK7_SNPB_A_0 K7_SN_m2_A D7_A K7_SN_m1_A VDD pfet_03v3 w=15.0u l=0.28u
XK7_SNPC_A_0 K7_SETN_A DNB_A K7_SN_m2_A VDD pfet_03v3 w=15.0u l=0.28u
XK7_PANA_A_0 K7_QP_A R_A VSS VSS nfet_03v3 w=2.5u l=0.28u
XK7_PANB_A_0 K7_QP_A K7_QPB_A VSS VSS nfet_03v3 w=2.5u l=0.28u
XK7_PAPA_A_0 K7_PA_m_A R_A VDD VDD pfet_03v3 w=10.0u l=0.28u
XK7_PAPB_A_0 K7_QP_A K7_QPB_A K7_PA_m_A VDD pfet_03v3 w=10.0u l=0.28u
XK7_PBNA_A_0 K7_QPB_A K7_SETP_A VSS VSS nfet_03v3 w=2.5u l=0.28u
XK7_PBNB_A_0 K7_QPB_A K7_QP_A VSS VSS nfet_03v3 w=2.5u l=0.28u
XK7_PBPA_A_0 K7_PB_m_A K7_SETP_A VDD VDD pfet_03v3 w=10.0u l=0.28u
XK7_PBPB_A_0 K7_QPB_A K7_QP_A K7_PB_m_A VDD pfet_03v3 w=10.0u l=0.28u
XK7_NANA_A_0 K7_QN_A R_A VSS VSS nfet_03v3 w=2.5u l=0.28u
XK7_NANB_A_0 K7_QN_A K7_QNB_A VSS VSS nfet_03v3 w=2.5u l=0.28u
XK7_NAPA_A_0 K7_NA_m_A R_A VDD VDD pfet_03v3 w=10.0u l=0.28u
XK7_NAPB_A_0 K7_QN_A K7_QNB_A K7_NA_m_A VDD pfet_03v3 w=10.0u l=0.28u
XK7_NBNA_A_0 K7_QNB_A K7_SETN_A VSS VSS nfet_03v3 w=2.5u l=0.28u
XK7_NBNB_A_0 K7_QNB_A K7_QN_A VSS VSS nfet_03v3 w=2.5u l=0.28u
XK7_NBPA_A_0 K7_NB_m_A K7_SETN_A VDD VDD pfet_03v3 w=10.0u l=0.28u
XK7_NBPB_A_0 K7_QNB_A K7_QN_A K7_NB_m_A VDD pfet_03v3 w=10.0u l=0.28u
XK7_DNA_A_0 D7_A K7_QPB_A K7_D_m_A VSS nfet_03v3 w=5.0u l=0.28u
XK7_DNB_A_0 K7_D_m_A K7_QNB_A VSS VSS nfet_03v3 w=5.0u l=0.28u
XK7_DPA_A_0 D7_A K7_QPB_A VDD VDD pfet_03v3 w=5.0u l=0.28u
XK7_DPB_A_0 D7_A K7_QNB_A VDD VDD pfet_03v3 w=5.0u l=0.28u
XDGP1N_A_0 GP1_A K7_QPB_A VSS VSS nfet_03v3 w=2.5u l=0.28u
XDGP1P_A_0 GP1_A K7_QPB_A VDD VDD pfet_03v3 w=5.0u l=0.28u
XDRP1N_A_0 RP1_A K7_QP_A VSS VSS nfet_03v3 w=2.5u l=0.28u
XDRP1P_A_0 RP1_A K7_QP_A VDD VDD pfet_03v3 w=5.0u l=0.28u
XDGN1N_A_0 GN1_A K7_QNB_A VSS VSS nfet_03v3 w=2.5u l=0.28u
XDGN1P_A_0 GN1_A K7_QNB_A VDD VDD pfet_03v3 w=5.0u l=0.28u
XDRN1N_A_0 RN1_A K7_QN_A VSS VSS nfet_03v3 w=2.5u l=0.28u
XDRN1P_A_0 RN1_A K7_QN_A VDD VDD pfet_03v3 w=5.0u l=0.28u
XK8_SNA_A_0 K8_SAB_A D7_A K8_S_m_A VSS nfet_03v3 w=5.0u l=0.28u
XK8_SNB_A_0 K8_S_m_A VALIDB_A VSS VSS nfet_03v3 w=5.0u l=0.28u
XK8_SPA_A_0 K8_SAB_A D7_A VDD VDD pfet_03v3 w=5.0u l=0.28u
XK8_SPB_A_0 K8_SAB_A VALIDB_A VDD VDD pfet_03v3 w=5.0u l=0.28u
XK8_LANA_A_0 K8_A_A K8_SAB_A K8_LA_m_A VSS nfet_03v3 w=5.0u l=0.28u
XK8_LANB_A_0 K8_LA_m_A K8_AB_A VSS VSS nfet_03v3 w=5.0u l=0.28u
XK8_LAPA_A_0 K8_A_A K8_SAB_A VDD VDD pfet_03v3 w=5.0u l=0.28u
XK8_LAPB_A_0 K8_A_A K8_AB_A VDD VDD pfet_03v3 w=5.0u l=0.28u
XK8_LBNA_A_0 K8_AB_A K8_A_A K8_LB_m_A VSS nfet_03v3 w=5.0u l=0.28u
XK8_LBNB_A_0 K8_LB_m_A RB_A VSS VSS nfet_03v3 w=5.0u l=0.28u
XK8_LBPA_A_0 K8_AB_A K8_A_A VDD VDD pfet_03v3 w=5.0u l=0.28u
XK8_LBPB_A_0 K8_AB_A RB_A VDD VDD pfet_03v3 w=5.0u l=0.28u
XK8_SPNA_A_0 K8_SETP_A K8_AB_A VSS VSS nfet_03v3 w=2.5u l=0.28u
XK8_SPNB_A_0 K8_SETP_A D8_A VSS VSS nfet_03v3 w=2.5u l=0.28u
XK8_SPNC_A_0 K8_SETP_A DPB_A VSS VSS nfet_03v3 w=2.5u l=0.28u
XK8_SPPA_A_0 K8_SP_m1_A K8_AB_A VDD VDD pfet_03v3 w=15.0u l=0.28u
XK8_SPPB_A_0 K8_SP_m2_A D8_A K8_SP_m1_A VDD pfet_03v3 w=15.0u l=0.28u
XK8_SPPC_A_0 K8_SETP_A DPB_A K8_SP_m2_A VDD pfet_03v3 w=15.0u l=0.28u
XK8_SNNA_A_0 K8_SETN_A K8_AB_A VSS VSS nfet_03v3 w=2.5u l=0.28u
XK8_SNNB_A_0 K8_SETN_A D8_A VSS VSS nfet_03v3 w=2.5u l=0.28u
XK8_SNNC_A_0 K8_SETN_A DNB_A VSS VSS nfet_03v3 w=2.5u l=0.28u
XK8_SNPA_A_0 K8_SN_m1_A K8_AB_A VDD VDD pfet_03v3 w=15.0u l=0.28u
XK8_SNPB_A_0 K8_SN_m2_A D8_A K8_SN_m1_A VDD pfet_03v3 w=15.0u l=0.28u
XK8_SNPC_A_0 K8_SETN_A DNB_A K8_SN_m2_A VDD pfet_03v3 w=15.0u l=0.28u
XK8_PANA_A_0 K8_QP_A R_A VSS VSS nfet_03v3 w=2.5u l=0.28u
XK8_PANB_A_0 K8_QP_A K8_QPB_A VSS VSS nfet_03v3 w=2.5u l=0.28u
XK8_PAPA_A_0 K8_PA_m_A R_A VDD VDD pfet_03v3 w=10.0u l=0.28u
XK8_PAPB_A_0 K8_QP_A K8_QPB_A K8_PA_m_A VDD pfet_03v3 w=10.0u l=0.28u
XK8_PBNA_A_0 K8_QPB_A K8_SETP_A VSS VSS nfet_03v3 w=2.5u l=0.28u
XK8_PBNB_A_0 K8_QPB_A K8_QP_A VSS VSS nfet_03v3 w=2.5u l=0.28u
XK8_PBPA_A_0 K8_PB_m_A K8_SETP_A VDD VDD pfet_03v3 w=10.0u l=0.28u
XK8_PBPB_A_0 K8_QPB_A K8_QP_A K8_PB_m_A VDD pfet_03v3 w=10.0u l=0.28u
XK8_NANA_A_0 K8_QN_A R_A VSS VSS nfet_03v3 w=2.5u l=0.28u
XK8_NANB_A_0 K8_QN_A K8_QNB_A VSS VSS nfet_03v3 w=2.5u l=0.28u
XK8_NAPA_A_0 K8_NA_m_A R_A VDD VDD pfet_03v3 w=10.0u l=0.28u
XK8_NAPB_A_0 K8_QN_A K8_QNB_A K8_NA_m_A VDD pfet_03v3 w=10.0u l=0.28u
XK8_NBNA_A_0 K8_QNB_A K8_SETN_A VSS VSS nfet_03v3 w=2.5u l=0.28u
XK8_NBNB_A_0 K8_QNB_A K8_QN_A VSS VSS nfet_03v3 w=2.5u l=0.28u
XK8_NBPA_A_0 K8_NB_m_A K8_SETN_A VDD VDD pfet_03v3 w=10.0u l=0.28u
XK8_NBPB_A_0 K8_QNB_A K8_QN_A K8_NB_m_A VDD pfet_03v3 w=10.0u l=0.28u
XK8_DNA_A_0 D8_A K8_QPB_A K8_D_m_A VSS nfet_03v3 w=5.0u l=0.28u
XK8_DNB_A_0 K8_D_m_A K8_QNB_A VSS VSS nfet_03v3 w=5.0u l=0.28u
XK8_DPA_A_0 D8_A K8_QPB_A VDD VDD pfet_03v3 w=5.0u l=0.28u
XK8_DPB_A_0 D8_A K8_QNB_A VDD VDD pfet_03v3 w=5.0u l=0.28u
XDGP0N_A_0 GP0_A K8_QPB_A VSS VSS nfet_03v3 w=2.5u l=0.28u
XDGP0P_A_0 GP0_A K8_QPB_A VDD VDD pfet_03v3 w=5.0u l=0.28u
XDRP0N_A_0 RP0_A K8_QP_A VSS VSS nfet_03v3 w=2.5u l=0.28u
XDRP0P_A_0 RP0_A K8_QP_A VDD VDD pfet_03v3 w=5.0u l=0.28u
XDGN0N_A_0 GN0_A K8_QNB_A VSS VSS nfet_03v3 w=2.5u l=0.28u
XDGN0P_A_0 GN0_A K8_QNB_A VDD VDD pfet_03v3 w=5.0u l=0.28u
XDRN0N_A_0 RN0_A K8_QN_A VSS VSS nfet_03v3 w=2.5u l=0.28u
XDRN0P_A_0 RN0_A K8_QN_A VDD VDD pfet_03v3 w=5.0u l=0.28u
XK9_SNA_A_0 K9_SAB_A D8_A K9_S_m_A VSS nfet_03v3 w=5.0u l=0.28u
XK9_SNB_A_0 K9_S_m_A VALIDB_A VSS VSS nfet_03v3 w=5.0u l=0.28u
XK9_SPA_A_0 K9_SAB_A D8_A VDD VDD pfet_03v3 w=5.0u l=0.28u
XK9_SPB_A_0 K9_SAB_A VALIDB_A VDD VDD pfet_03v3 w=5.0u l=0.28u
XK9_LANA_A_0 K9_A_A K9_SAB_A K9_LA_m_A VSS nfet_03v3 w=5.0u l=0.28u
XK9_LANB_A_0 K9_LA_m_A K9_AB_A VSS VSS nfet_03v3 w=5.0u l=0.28u
XK9_LAPA_A_0 K9_A_A K9_SAB_A VDD VDD pfet_03v3 w=5.0u l=0.28u
XK9_LAPB_A_0 K9_A_A K9_AB_A VDD VDD pfet_03v3 w=5.0u l=0.28u
XK9_LBNA_A_0 K9_AB_A K9_A_A K9_LB_m_A VSS nfet_03v3 w=5.0u l=0.28u
XK9_LBNB_A_0 K9_LB_m_A RB_A VSS VSS nfet_03v3 w=5.0u l=0.28u
XK9_LBPA_A_0 K9_AB_A K9_A_A VDD VDD pfet_03v3 w=5.0u l=0.28u
XK9_LBPB_A_0 K9_AB_A RB_A VDD VDD pfet_03v3 w=5.0u l=0.28u
XK9_SPNA_A_0 K9_SETP_A K9_AB_A VSS VSS nfet_03v3 w=2.5u l=0.28u
XK9_SPNB_A_0 K9_SETP_A D9_A VSS VSS nfet_03v3 w=2.5u l=0.28u
XK9_SPNC_A_0 K9_SETP_A DPB_A VSS VSS nfet_03v3 w=2.5u l=0.28u
XK9_SPPA_A_0 K9_SP_m1_A K9_AB_A VDD VDD pfet_03v3 w=15.0u l=0.28u
XK9_SPPB_A_0 K9_SP_m2_A D9_A K9_SP_m1_A VDD pfet_03v3 w=15.0u l=0.28u
XK9_SPPC_A_0 K9_SETP_A DPB_A K9_SP_m2_A VDD pfet_03v3 w=15.0u l=0.28u
XK9_SNNA_A_0 K9_SETN_A K9_AB_A VSS VSS nfet_03v3 w=2.5u l=0.28u
XK9_SNNB_A_0 K9_SETN_A D9_A VSS VSS nfet_03v3 w=2.5u l=0.28u
XK9_SNNC_A_0 K9_SETN_A DNB_A VSS VSS nfet_03v3 w=2.5u l=0.28u
XK9_SNPA_A_0 K9_SN_m1_A K9_AB_A VDD VDD pfet_03v3 w=15.0u l=0.28u
XK9_SNPB_A_0 K9_SN_m2_A D9_A K9_SN_m1_A VDD pfet_03v3 w=15.0u l=0.28u
XK9_SNPC_A_0 K9_SETN_A DNB_A K9_SN_m2_A VDD pfet_03v3 w=15.0u l=0.28u
XK9_PANA_A_0 K9_QP_A R_A VSS VSS nfet_03v3 w=2.5u l=0.28u
XK9_PANB_A_0 K9_QP_A K9_QPB_A VSS VSS nfet_03v3 w=2.5u l=0.28u
XK9_PAPA_A_0 K9_PA_m_A R_A VDD VDD pfet_03v3 w=10.0u l=0.28u
XK9_PAPB_A_0 K9_QP_A K9_QPB_A K9_PA_m_A VDD pfet_03v3 w=10.0u l=0.28u
XK9_PBNA_A_0 K9_QPB_A K9_SETP_A VSS VSS nfet_03v3 w=2.5u l=0.28u
XK9_PBNB_A_0 K9_QPB_A K9_QP_A VSS VSS nfet_03v3 w=2.5u l=0.28u
XK9_PBPA_A_0 K9_PB_m_A K9_SETP_A VDD VDD pfet_03v3 w=10.0u l=0.28u
XK9_PBPB_A_0 K9_QPB_A K9_QP_A K9_PB_m_A VDD pfet_03v3 w=10.0u l=0.28u
XK9_NANA_A_0 K9_QN_A R_A VSS VSS nfet_03v3 w=2.5u l=0.28u
XK9_NANB_A_0 K9_QN_A K9_QNB_A VSS VSS nfet_03v3 w=2.5u l=0.28u
XK9_NAPA_A_0 K9_NA_m_A R_A VDD VDD pfet_03v3 w=10.0u l=0.28u
XK9_NAPB_A_0 K9_QN_A K9_QNB_A K9_NA_m_A VDD pfet_03v3 w=10.0u l=0.28u
XK9_NBNA_A_0 K9_QNB_A K9_SETN_A VSS VSS nfet_03v3 w=2.5u l=0.28u
XK9_NBNB_A_0 K9_QNB_A K9_QN_A VSS VSS nfet_03v3 w=2.5u l=0.28u
XK9_NBPA_A_0 K9_NB_m_A K9_SETN_A VDD VDD pfet_03v3 w=10.0u l=0.28u
XK9_NBPB_A_0 K9_QNB_A K9_QN_A K9_NB_m_A VDD pfet_03v3 w=10.0u l=0.28u
XK9_DNA_A_0 D9_A K9_QPB_A K9_D_m_A VSS nfet_03v3 w=5.0u l=0.28u
XK9_DNB_A_0 K9_D_m_A K9_QNB_A VSS VSS nfet_03v3 w=5.0u l=0.28u
XK9_DPA_A_0 D9_A K9_QPB_A VDD VDD pfet_03v3 w=5.0u l=0.28u
XK9_DPB_A_0 D9_A K9_QNB_A VDD VDD pfet_03v3 w=5.0u l=0.28u
XXL_A D9_A DONE EN OVERLOAD VDD VSS K0_QP_A K1_QP_A K2_QP_A K3_QP_A K4_QP_A K5_QP_A K6_QP_A K7_QP_A K8_QP_A K9_QP_A CODE0 CODE1 CODE2 CODE3 CODE4 CODE5 CODE6 CODE7 CODE8 CODE9 adc_code_reg
XGTZNA_B_0 TZ_B TEST0 VSS VSS nfet_03v3 w=1.0u l=0.28u
XGTZNB_B_0 TZ_B TEST1 VSS VSS nfet_03v3 w=1.0u l=0.28u
XGTZPA_B_0 GTZ_m_B TEST0 VDD VDD pfet_03v3 w=4.0u l=0.28u
XGTZPB_B_0 TZ_B TEST1 GTZ_m_B VDD pfet_03v3 w=4.0u l=0.28u
XGTZBN_B_0 TZB_B TZ_B VSS VSS nfet_03v3 w=1.0u l=0.28u
XGTZBP_B_0 TZB_B TZ_B VDD VDD pfet_03v3 w=2.0u l=0.28u
XGSENA_B_0 SEB_B SAMPLE_B GSE_m_B VSS nfet_03v3 w=2.0u l=0.28u
XGSENB_B_0 GSE_m_B EN_B VSS VSS nfet_03v3 w=2.0u l=0.28u
XGSEPA_B_0 SEB_B SAMPLE_B VDD VDD pfet_03v3 w=2.0u l=0.28u
XGSEPB_B_0 SEB_B EN_B VDD VDD pfet_03v3 w=2.0u l=0.28u
XGSEIN_B_0 SEN_B SEB_B VSS VSS nfet_03v3 w=2u l=0.28u
XGSEIP_B_0 SEN_B SEB_B VDD VDD pfet_03v3 w=4u l=0.28u
XGBTNA_B_0 BOOTBL_B SEN_B GBT_m_B VSS nfet_03v3 w=4u l=0.28u
XGBTNB_B_0 GBT_m_B TZ_B VSS VSS nfet_03v3 w=4u l=0.28u
XGBTPA_B_0 BOOTBL_B SEN_B VDD VDD pfet_03v3 w=4u l=0.28u
XGBTPB_B_0 BOOTBL_B TZ_B VDD VDD pfet_03v3 w=4u l=0.28u
XGBTIN_B_0 BOOTL_B BOOTBL_B VSS VSS nfet_03v3 w=4u l=0.28u
XGBTIP_B_0 BOOTL_B BOOTBL_B VDD VDD pfet_03v3 w=8u l=0.28u
XGVTNA_B_0 VCMTB_B SEN_B GVT_m_B VSS nfet_03v3 w=2.0u l=0.28u
XGVTNB_B_0 GVT_m_B TZB_B VSS VSS nfet_03v3 w=2.0u l=0.28u
XGVTPA_B_0 VCMTB_B SEN_B VDD VDD pfet_03v3 w=2.0u l=0.28u
XGVTPB_B_0 VCMTB_B TZB_B VDD VDD pfet_03v3 w=2.0u l=0.28u
XGVTIN_B_0 VCMTL_B VCMTB_B VSS VSS nfet_03v3 w=2u l=0.28u
XGVTIP_B_0 VCMTL_B VCMTB_B VDD VDD pfet_03v3 w=4u l=0.28u
XGLRAN_B_0 LSBRB_B SEN_B VSS VSS nfet_03v3 w=1.0u l=0.28u
XGLRAP_B_0 LSBRB_B SEN_B VDD VDD pfet_03v3 w=2.0u l=0.28u
XGLRBN_B_0 LSBRL_B LSBRB_B VSS VSS nfet_03v3 w=2u l=0.28u
XGLRBP_B_0 LSBRL_B LSBRB_B VDD VDD pfet_03v3 w=4u l=0.28u
XSPMS_B_0 INP SPg_B TOPP_B VSS nfet_03v3 w=8u l=0.28u
XSPCB_B_0 SPtb_B SPbb_B cap_mim_2f0_m4m5_noshield c_width=10u c_length=10u
XSPM1_B_0 SPbb_B BOOTBL_B VSS VSS nfet_03v3 w=2u l=0.28u
XSPM2_B_0 SPtb_B SPg_B VDD SPtb_B pfet_03v3 w=2u l=0.28u
XSPM3_B_0 SPg_B SPh_B SPtb_B SPtb_B pfet_03v3 w=4u l=0.28u
XSPM4_B_0 SPh_B BOOTL_B SPbb_B VSS nfet_03v3 w=1u l=0.28u
XSPM5_B_0 SPh_B BOOTL_B VDD VDD pfet_03v3 w=1u l=0.28u
XSPM6_B_0 SPbb_B SPg_B INP VSS nfet_03v3 w=4u l=0.28u
XSPM7_B_0 SPg_B VDD SPgx_B VSS nfet_03v3 w=2u l=0.28u
XSPM8_B_0 SPgx_B BOOTBL_B VSS VSS nfet_03v3 w=2u l=0.28u
XVTP_B_0 TOPP_B VCMTL_B VCM VSS nfet_03v3 w=2u l=0.28u
XLRP_B_0 LSBP_B LSBRL_B VCM VSS nfet_03v3 w=1u l=0.28u
XSNMS_B_0 INN SNg_B TOPN_B VSS nfet_03v3 w=8u l=0.28u
XSNCB_B_0 SNtb_B SNbb_B cap_mim_2f0_m4m5_noshield c_width=10u c_length=10u
XSNM1_B_0 SNbb_B BOOTBL_B VSS VSS nfet_03v3 w=2u l=0.28u
XSNM2_B_0 SNtb_B SNg_B VDD SNtb_B pfet_03v3 w=2u l=0.28u
XSNM3_B_0 SNg_B SNh_B SNtb_B SNtb_B pfet_03v3 w=4u l=0.28u
XSNM4_B_0 SNh_B BOOTL_B SNbb_B VSS nfet_03v3 w=1u l=0.28u
XSNM5_B_0 SNh_B BOOTL_B VDD VDD pfet_03v3 w=1u l=0.28u
XSNM6_B_0 SNbb_B SNg_B INN VSS nfet_03v3 w=4u l=0.28u
XSNM7_B_0 SNg_B VDD SNgx_B VSS nfet_03v3 w=2u l=0.28u
XSNM8_B_0 SNgx_B BOOTBL_B VSS VSS nfet_03v3 w=2u l=0.28u
XVTN_B_0 TOPN_B VCMTL_B VCM VSS nfet_03v3 w=2u l=0.28u
XLRN_B_0 LSBN_B LSBRL_B VCM VSS nfet_03v3 w=1u l=0.28u
XQB1N_B_0 Qckb_B CMPCLK_B VSS VSS nfet_03v3 w=3u l=0.28u
XQB1P_B_0 Qckb_B CMPCLK_B VDD VDD pfet_03v3 w=6u l=0.28u
XQB2N_B_0 Qck_B Qckb_B VSS VSS nfet_03v3 w=12u l=0.28u
XQB2P_B_0 Qck_B Qckb_B VDD VDD pfet_03v3 w=12.0u l=0.28u
XQB2P_B_1 Qck_B Qckb_B VDD VDD pfet_03v3 w=12.0u l=0.28u
XQMT_B_0 Qct_B Qck_B VSS VSS nfet_03v3 w=12u l=0.28u
XQMIP_B_0 Qcn1_B TOPP_B Qct_B VSS nfet_03v3 w=8u l=0.28u
XQMIN_B_0 Qcn2_B TOPN_B Qct_B VSS nfet_03v3 w=8u l=0.28u
XQMNP_B_0 Qqn_B Qqp_B Qcn1_B VSS nfet_03v3 w=8u l=0.28u
XQMNN_B_0 Qqp_B Qqn_B Qcn2_B VSS nfet_03v3 w=8u l=0.28u
XQMPP_B_0 Qqn_B Qqp_B VDD VDD pfet_03v3 w=8u l=0.28u
XQMPN_B_0 Qqp_B Qqn_B VDD VDD pfet_03v3 w=8u l=0.28u
XQMR1_B_0 Qcn1_B Qck_B VDD VDD pfet_03v3 w=4u l=0.28u
XQMR2_B_0 Qcn2_B Qck_B VDD VDD pfet_03v3 w=4u l=0.28u
XQMRP_B_0 Qqp_B Qck_B VDD VDD pfet_03v3 w=4u l=0.28u
XQMRN_B_0 Qqn_B Qck_B VDD VDD pfet_03v3 w=4u l=0.28u
XQIPN_B_0 DP_B Qqn_B VSS VSS nfet_03v3 w=6u l=0.28u
XQIPP_B_0 DP_B Qqn_B VDD VDD pfet_03v3 w=12u l=0.28u
XQINN_B_0 DN_B Qqp_B VSS VSS nfet_03v3 w=6u l=0.28u
XQINP_B_0 DN_B Qqp_B VDD VDD pfet_03v3 w=12u l=0.28u
XMGP0_B_0 BOTP0_B GP0_B VSS VSS nfet_03v3 w=1u l=0.28u
XMRP0_B_0 BOTP0_B RP0_B VREF VSS nfet_03v3 w=1u l=0.28u
XMGP1_B_0 BOTP1_B GP1_B VSS VSS nfet_03v3 w=1u l=0.28u
XMRP1_B_0 BOTP1_B RP1_B VREF VSS nfet_03v3 w=1u l=0.28u
XMGP2_B_0 BOTP2_B GP2_B VSS VSS nfet_03v3 w=1.2u l=0.28u
XMRP2_B_0 BOTP2_B RP2_B VREF VSS nfet_03v3 w=1.2u l=0.28u
XMGP3_B_0 BOTP3_B GP3_B VSS VSS nfet_03v3 w=2.5u l=0.28u
XMRP3_B_0 BOTP3_B RP3_B VREF VSS nfet_03v3 w=2.5u l=0.28u
XMGP4_B_0 BOTP4_B GP4_B VSS VSS nfet_03v3 w=5u l=0.28u
XMRP4_B_0 BOTP4_B RP4_B VREF VSS nfet_03v3 w=5u l=0.28u
XMGP5_B_0 BOTP5_B GP5_B VSS VSS nfet_03v3 w=10u l=0.28u
XMRP5_B_0 BOTP5_B RP5_B VREF VSS nfet_03v3 w=10u l=0.28u
XMGP6_B_0 BOTP6_B GP6_B VSS VSS nfet_03v3 w=1u l=0.28u
XMRP6_B_0 BOTP6_B RP6_B VREF VSS nfet_03v3 w=1u l=0.28u
XMGP7_B_0 BOTP7_B GP7_B VSS VSS nfet_03v3 w=2u l=0.28u
XMRP7_B_0 BOTP7_B RP7_B VREF VSS nfet_03v3 w=2u l=0.28u
XMGP8_B_0 BOTP8_B GP8_B VSS VSS nfet_03v3 w=4u l=0.28u
XMRP8_B_0 BOTP8_B RP8_B VREF VSS nfet_03v3 w=4u l=0.28u
XMGN0_B_0 BOTN0_B GN0_B VSS VSS nfet_03v3 w=1u l=0.28u
XMRN0_B_0 BOTN0_B RN0_B VREF VSS nfet_03v3 w=1u l=0.28u
XMGN1_B_0 BOTN1_B GN1_B VSS VSS nfet_03v3 w=1u l=0.28u
XMRN1_B_0 BOTN1_B RN1_B VREF VSS nfet_03v3 w=1u l=0.28u
XMGN2_B_0 BOTN2_B GN2_B VSS VSS nfet_03v3 w=1.2u l=0.28u
XMRN2_B_0 BOTN2_B RN2_B VREF VSS nfet_03v3 w=1.2u l=0.28u
XMGN3_B_0 BOTN3_B GN3_B VSS VSS nfet_03v3 w=2.5u l=0.28u
XMRN3_B_0 BOTN3_B RN3_B VREF VSS nfet_03v3 w=2.5u l=0.28u
XMGN4_B_0 BOTN4_B GN4_B VSS VSS nfet_03v3 w=5u l=0.28u
XMRN4_B_0 BOTN4_B RN4_B VREF VSS nfet_03v3 w=5u l=0.28u
XMGN5_B_0 BOTN5_B GN5_B VSS VSS nfet_03v3 w=10u l=0.28u
XMRN5_B_0 BOTN5_B RN5_B VREF VSS nfet_03v3 w=10u l=0.28u
XMGN6_B_0 BOTN6_B GN6_B VSS VSS nfet_03v3 w=1u l=0.28u
XMRN6_B_0 BOTN6_B RN6_B VREF VSS nfet_03v3 w=1u l=0.28u
XMGN7_B_0 BOTN7_B GN7_B VSS VSS nfet_03v3 w=2u l=0.28u
XMRN7_B_0 BOTN7_B RN7_B VREF VSS nfet_03v3 w=2u l=0.28u
XMGN8_B_0 BOTN8_B GN8_B VSS VSS nfet_03v3 w=4u l=0.28u
XMRN8_B_0 BOTN8_B RN8_B VREF VSS nfet_03v3 w=4u l=0.28u
XCP8_B_0 TOPP_B BOTP8_B cap_mim_2f0_m4m5_noshield c_width=5u c_length=5u
XCP8_B_1 TOPP_B BOTP8_B cap_mim_2f0_m4m5_noshield c_width=5u c_length=5u
XCP8_B_2 TOPP_B BOTP8_B cap_mim_2f0_m4m5_noshield c_width=5u c_length=5u
XCP8_B_3 TOPP_B BOTP8_B cap_mim_2f0_m4m5_noshield c_width=5u c_length=5u
XCP7_B_0 TOPP_B BOTP7_B cap_mim_2f0_m4m5_noshield c_width=5u c_length=5u
XCP7_B_1 TOPP_B BOTP7_B cap_mim_2f0_m4m5_noshield c_width=5u c_length=5u
XCP6_B_0 TOPP_B BOTP6_B cap_mim_2f0_m4m5_noshield c_width=5u c_length=5u
XCBP_B_0 LSBP_B TOPP_B cap_mim_2f0_m4m5_noshield c_width=5.04u c_length=5.04u
XCP5_B_0 LSBP_B BOTP5_B cap_mim_2f0_m4m5_noshield c_width=29.37u c_length=29.37u
XCP4_B_0 LSBP_B BOTP4_B cap_mim_2f0_m4m5_noshield c_width=20.695u c_length=20.695u
XCP3_B_0 LSBP_B BOTP3_B cap_mim_2f0_m4m5_noshield c_width=14.565u c_length=14.565u
XCP2_B_0 LSBP_B BOTP2_B cap_mim_2f0_m4m5_noshield c_width=10.23u c_length=10.23u
XCP1_B_0 LSBP_B BOTP1_B cap_mim_2f0_m4m5_noshield c_width=7.165u c_length=7.165u
XCP0_B_0 LSBP_B BOTP0_B cap_mim_2f0_m4m5_noshield c_width=5.0u c_length=5.0u
XCDP_B_0 LSBP_B VSS cap_mim_2f0_m4m5_noshield c_width=5u c_length=5u
XCN8_B_0 TOPN_B BOTN8_B cap_mim_2f0_m4m5_noshield c_width=5u c_length=5u
XCN8_B_1 TOPN_B BOTN8_B cap_mim_2f0_m4m5_noshield c_width=5u c_length=5u
XCN8_B_2 TOPN_B BOTN8_B cap_mim_2f0_m4m5_noshield c_width=5u c_length=5u
XCN8_B_3 TOPN_B BOTN8_B cap_mim_2f0_m4m5_noshield c_width=5u c_length=5u
XCN7_B_0 TOPN_B BOTN7_B cap_mim_2f0_m4m5_noshield c_width=5u c_length=5u
XCN7_B_1 TOPN_B BOTN7_B cap_mim_2f0_m4m5_noshield c_width=5u c_length=5u
XCN6_B_0 TOPN_B BOTN6_B cap_mim_2f0_m4m5_noshield c_width=5u c_length=5u
XCBN_B_0 LSBN_B TOPN_B cap_mim_2f0_m4m5_noshield c_width=5.04u c_length=5.04u
XCN5_B_0 LSBN_B BOTN5_B cap_mim_2f0_m4m5_noshield c_width=29.37u c_length=29.37u
XCN4_B_0 LSBN_B BOTN4_B cap_mim_2f0_m4m5_noshield c_width=20.695u c_length=20.695u
XCN3_B_0 LSBN_B BOTN3_B cap_mim_2f0_m4m5_noshield c_width=14.565u c_length=14.565u
XCN2_B_0 LSBN_B BOTN2_B cap_mim_2f0_m4m5_noshield c_width=10.23u c_length=10.23u
XCN1_B_0 LSBN_B BOTN1_B cap_mim_2f0_m4m5_noshield c_width=7.165u c_length=7.165u
XCN0_B_0 LSBN_B BOTN0_B cap_mim_2f0_m4m5_noshield c_width=5.0u c_length=5.0u
XCDN_B_0 LSBN_B VSS cap_mim_2f0_m4m5_noshield c_width=5u c_length=5u
XCRNA_B_0 R_B SEB_B CR_m_B VSS nfet_03v3 w=5.0u l=0.28u
XCRNB_B_0 CR_m_B EN_B VSS VSS nfet_03v3 w=5.0u l=0.28u
XCRPA_B_0 R_B SEB_B VDD VDD pfet_03v3 w=5.0u l=0.28u
XCRPB_B_0 R_B EN_B VDD VDD pfet_03v3 w=5.0u l=0.28u
XCRBN_B_0 RB_B R_B VSS VSS nfet_03v3 w=2.5u l=0.28u
XCRBP_B_0 RB_B R_B VDD VDD pfet_03v3 w=5.0u l=0.28u
XDT1N0_B_0 DT1_0_B SEN_B VSS VSS nfet_03v3 w=2.5u l=0.28u
XDT1P0_B_0 DT1_0_B SEN_B VDD VDD pfet_03v3 w=5.0u l=0.28u
XDT1N1_B_0 SEN_d1_B DT1_0_B VSS VSS nfet_03v3 w=2.5u l=0.28u
XDT1P1_B_0 SEN_d1_B DT1_0_B VDD VDD pfet_03v3 w=5.0u l=0.28u
XOT1NA_B_0 TD1B_B SEN_B VSS VSS nfet_03v3 w=2.5u l=0.28u
XOT1NB_B_0 TD1B_B SEN_d1_B VSS VSS nfet_03v3 w=2.5u l=0.28u
XOT1PA_B_0 OT1_m_B SEN_B VDD VDD pfet_03v3 w=10.0u l=0.28u
XOT1PB_B_0 TD1B_B SEN_d1_B OT1_m_B VDD pfet_03v3 w=10.0u l=0.28u
XDT2N0_B_0 DT2_0_B SEN_d1_B VSS VSS nfet_03v3 w=2.5u l=0.28u
XDT2P0_B_0 DT2_0_B SEN_d1_B VDD VDD pfet_03v3 w=5.0u l=0.28u
XDT2N1_B_0 SEN_d2_B DT2_0_B VSS VSS nfet_03v3 w=2.5u l=0.28u
XDT2P1_B_0 SEN_d2_B DT2_0_B VDD VDD pfet_03v3 w=5.0u l=0.28u
XOT2NA_B_0 TD2B_B SEN_B VSS VSS nfet_03v3 w=2.5u l=0.28u
XOT2NB_B_0 TD2B_B SEN_d1_B VSS VSS nfet_03v3 w=2.5u l=0.28u
XOT2NC_B_0 TD2B_B SEN_d2_B VSS VSS nfet_03v3 w=2.5u l=0.28u
XOT2PA_B_0 OT2_m1_B SEN_B VDD VDD pfet_03v3 w=15.0u l=0.28u
XOT2PB_B_0 OT2_m2_B SEN_d1_B OT2_m1_B VDD pfet_03v3 w=15.0u l=0.28u
XOT2PC_B_0 TD2B_B SEN_d2_B OT2_m2_B VDD pfet_03v3 w=15.0u l=0.28u
XIT2N_B_0 TD2_B TD2B_B VSS VSS nfet_03v3 w=2.5u l=0.28u
XIT2P_B_0 TD2_B TD2B_B VDD VDD pfet_03v3 w=5.0u l=0.28u
XORNNA_B_0 RUN_B TD2_B VSS VSS nfet_03v3 w=2.5u l=0.28u
XORNNB_B_0 RUN_B D9_B VSS VSS nfet_03v3 w=2.5u l=0.28u
XORNNC_B_0 RUN_B ENB_B VSS VSS nfet_03v3 w=2.5u l=0.28u
XORNPA_B_0 ORN_m1_B TD2_B VDD VDD pfet_03v3 w=15.0u l=0.28u
XORNPB_B_0 ORN_m2_B D9_B ORN_m1_B VDD pfet_03v3 w=15.0u l=0.28u
XORNPC_B_0 RUN_B ENB_B ORN_m2_B VDD pfet_03v3 w=15.0u l=0.28u
XIRNN_B_0 RUNB_B RUN_B VSS VSS nfet_03v3 w=2.5u l=0.28u
XIRNP_B_0 RUNB_B RUN_B VDD VDD pfet_03v3 w=5.0u l=0.28u
XOVNA_B_0 VALIDB_B DP_B VSS VSS nfet_03v3 w=5.0u l=0.28u
XOVNB_B_0 VALIDB_B DN_B VSS VSS nfet_03v3 w=5.0u l=0.28u
XOVPA_B_0 OV_m_B DP_B VDD VDD pfet_03v3 w=10.0u l=0.28u
XOVPA_B_1 OV_m_B DP_B VDD VDD pfet_03v3 w=10.0u l=0.28u
XOVPB_B_0 VALIDB_B DN_B OV_m_B VDD pfet_03v3 w=10.0u l=0.28u
XOVPB_B_1 VALIDB_B DN_B OV_m_B VDD pfet_03v3 w=10.0u l=0.28u
XIVN_B_0 VALID_B VALIDB_B VSS VSS nfet_03v3 w=5.0u l=0.28u
XIVP_B_0 VALID_B VALIDB_B VDD VDD pfet_03v3 w=10.0u l=0.28u
XIDPN_B_0 DPB_B DP_B VSS VSS nfet_03v3 w=5.0u l=0.28u
XIDPP_B_0 DPB_B DP_B VDD VDD pfet_03v3 w=10.0u l=0.28u
XIDNN_B_0 DNB_B DN_B VSS VSS nfet_03v3 w=5.0u l=0.28u
XIDNP_B_0 DNB_B DN_B VDD VDD pfet_03v3 w=10.0u l=0.28u
XOKNA_B_0 CMPCLK_B DP_B VSS VSS nfet_03v3 w=5.0u l=0.28u
XOKNB_B_0 CMPCLK_B DN_B VSS VSS nfet_03v3 w=5.0u l=0.28u
XOKNC_B_0 CMPCLK_B RUNB_B VSS VSS nfet_03v3 w=5.0u l=0.28u
XOKPA_B_0 OK_m1_B DP_B VDD VDD pfet_03v3 w=15.0u l=0.28u
XOKPA_B_1 OK_m1_B DP_B VDD VDD pfet_03v3 w=15.0u l=0.28u
XOKPB_B_0 OK_m2_B DN_B OK_m1_B VDD pfet_03v3 w=15.0u l=0.28u
XOKPB_B_1 OK_m2_B DN_B OK_m1_B VDD pfet_03v3 w=15.0u l=0.28u
XOKPC_B_0 CMPCLK_B RUNB_B OK_m2_B VDD pfet_03v3 w=15.0u l=0.28u
XOKPC_B_1 CMPCLK_B RUNB_B OK_m2_B VDD pfet_03v3 w=15.0u l=0.28u
XIT0N_B_0 TEST0B_B TEST0 VSS VSS nfet_03v3 w=2.5u l=0.28u
XIT0P_B_0 TEST0B_B TEST0 VDD VDD pfet_03v3 w=5.0u l=0.28u
XIT1N_B_0 TEST1B_B TEST1 VSS VSS nfet_03v3 w=2.5u l=0.28u
XIT1P_B_0 TEST1B_B TEST1 VDD VDD pfet_03v3 w=5.0u l=0.28u
XOFPNA_B_0 FP_B TD1B_B VSS VSS nfet_03v3 w=2.5u l=0.28u
XOFPNB_B_0 FP_B TEST1B_B VSS VSS nfet_03v3 w=2.5u l=0.28u
XOFPNC_B_0 FP_B TEST0 VSS VSS nfet_03v3 w=2.5u l=0.28u
XOFPPA_B_0 OFP_m1_B TD1B_B VDD VDD pfet_03v3 w=15.0u l=0.28u
XOFPPB_B_0 OFP_m2_B TEST1B_B OFP_m1_B VDD pfet_03v3 w=15.0u l=0.28u
XOFPPC_B_0 FP_B TEST0 OFP_m2_B VDD pfet_03v3 w=15.0u l=0.28u
XOFNNA_B_0 FN_B TD1B_B VSS VSS nfet_03v3 w=2.5u l=0.28u
XOFNNB_B_0 FN_B TEST1B_B VSS VSS nfet_03v3 w=2.5u l=0.28u
XOFNNC_B_0 FN_B TEST0B_B VSS VSS nfet_03v3 w=2.5u l=0.28u
XOFNPA_B_0 OFN_m1_B TD1B_B VDD VDD pfet_03v3 w=15.0u l=0.28u
XOFNPB_B_0 OFN_m2_B TEST1B_B OFN_m1_B VDD pfet_03v3 w=15.0u l=0.28u
XOFNPC_B_0 FN_B TEST0B_B OFN_m2_B VDD pfet_03v3 w=15.0u l=0.28u
XK0_SNA_B_0 K0_SAB_B RUN_B K0_S_m_B VSS nfet_03v3 w=5.0u l=0.28u
XK0_SNB_B_0 K0_S_m_B VALIDB_B VSS VSS nfet_03v3 w=5.0u l=0.28u
XK0_SPA_B_0 K0_SAB_B RUN_B VDD VDD pfet_03v3 w=5.0u l=0.28u
XK0_SPB_B_0 K0_SAB_B VALIDB_B VDD VDD pfet_03v3 w=5.0u l=0.28u
XK0_LANA_B_0 K0_A_B K0_SAB_B K0_LA_m_B VSS nfet_03v3 w=5.0u l=0.28u
XK0_LANB_B_0 K0_LA_m_B K0_AB_B VSS VSS nfet_03v3 w=5.0u l=0.28u
XK0_LAPA_B_0 K0_A_B K0_SAB_B VDD VDD pfet_03v3 w=5.0u l=0.28u
XK0_LAPB_B_0 K0_A_B K0_AB_B VDD VDD pfet_03v3 w=5.0u l=0.28u
XK0_LBNA_B_0 K0_AB_B K0_A_B K0_LB_m_B VSS nfet_03v3 w=5.0u l=0.28u
XK0_LBNB_B_0 K0_LB_m_B RB_B VSS VSS nfet_03v3 w=5.0u l=0.28u
XK0_LBPA_B_0 K0_AB_B K0_A_B VDD VDD pfet_03v3 w=5.0u l=0.28u
XK0_LBPB_B_0 K0_AB_B RB_B VDD VDD pfet_03v3 w=5.0u l=0.28u
XK0_SPNA_B_0 K0_SETP_B K0_AB_B VSS VSS nfet_03v3 w=2.5u l=0.28u
XK0_SPNB_B_0 K0_SETP_B D0_B VSS VSS nfet_03v3 w=2.5u l=0.28u
XK0_SPNC_B_0 K0_SETP_B DPB_B VSS VSS nfet_03v3 w=2.5u l=0.28u
XK0_SPPA_B_0 K0_SP_m1_B K0_AB_B VDD VDD pfet_03v3 w=15.0u l=0.28u
XK0_SPPB_B_0 K0_SP_m2_B D0_B K0_SP_m1_B VDD pfet_03v3 w=15.0u l=0.28u
XK0_SPPC_B_0 K0_SETP_B DPB_B K0_SP_m2_B VDD pfet_03v3 w=15.0u l=0.28u
XK0_SNNA_B_0 K0_SETN_B K0_AB_B VSS VSS nfet_03v3 w=2.5u l=0.28u
XK0_SNNB_B_0 K0_SETN_B D0_B VSS VSS nfet_03v3 w=2.5u l=0.28u
XK0_SNNC_B_0 K0_SETN_B DNB_B VSS VSS nfet_03v3 w=2.5u l=0.28u
XK0_SNPA_B_0 K0_SN_m1_B K0_AB_B VDD VDD pfet_03v3 w=15.0u l=0.28u
XK0_SNPB_B_0 K0_SN_m2_B D0_B K0_SN_m1_B VDD pfet_03v3 w=15.0u l=0.28u
XK0_SNPC_B_0 K0_SETN_B DNB_B K0_SN_m2_B VDD pfet_03v3 w=15.0u l=0.28u
XK0_PANA_B_0 K0_QP_B R_B VSS VSS nfet_03v3 w=2.5u l=0.28u
XK0_PANB_B_0 K0_QP_B K0_QPB_B VSS VSS nfet_03v3 w=2.5u l=0.28u
XK0_PAPA_B_0 K0_PA_m_B R_B VDD VDD pfet_03v3 w=10.0u l=0.28u
XK0_PAPB_B_0 K0_QP_B K0_QPB_B K0_PA_m_B VDD pfet_03v3 w=10.0u l=0.28u
XK0_PBNA_B_0 K0_QPB_B K0_SETP_B VSS VSS nfet_03v3 w=2.5u l=0.28u
XK0_PBNB_B_0 K0_QPB_B K0_QP_B VSS VSS nfet_03v3 w=2.5u l=0.28u
XK0_PBPA_B_0 K0_PB_m_B K0_SETP_B VDD VDD pfet_03v3 w=10.0u l=0.28u
XK0_PBPB_B_0 K0_QPB_B K0_QP_B K0_PB_m_B VDD pfet_03v3 w=10.0u l=0.28u
XK0_NANA_B_0 K0_QN_B R_B VSS VSS nfet_03v3 w=2.5u l=0.28u
XK0_NANB_B_0 K0_QN_B K0_QNB_B VSS VSS nfet_03v3 w=2.5u l=0.28u
XK0_NAPA_B_0 K0_NA_m_B R_B VDD VDD pfet_03v3 w=10.0u l=0.28u
XK0_NAPB_B_0 K0_QN_B K0_QNB_B K0_NA_m_B VDD pfet_03v3 w=10.0u l=0.28u
XK0_NBNA_B_0 K0_QNB_B K0_SETN_B VSS VSS nfet_03v3 w=2.5u l=0.28u
XK0_NBNB_B_0 K0_QNB_B K0_QN_B VSS VSS nfet_03v3 w=2.5u l=0.28u
XK0_NBPA_B_0 K0_NB_m_B K0_SETN_B VDD VDD pfet_03v3 w=10.0u l=0.28u
XK0_NBPB_B_0 K0_QNB_B K0_QN_B K0_NB_m_B VDD pfet_03v3 w=10.0u l=0.28u
XK0_DNA_B_0 D0_B K0_QPB_B K0_D_m_B VSS nfet_03v3 w=5.0u l=0.28u
XK0_DNB_B_0 K0_D_m_B K0_QNB_B VSS VSS nfet_03v3 w=5.0u l=0.28u
XK0_DPA_B_0 D0_B K0_QPB_B VDD VDD pfet_03v3 w=5.0u l=0.28u
XK0_DPB_B_0 D0_B K0_QNB_B VDD VDD pfet_03v3 w=5.0u l=0.28u
XDGP8N_B_0 GP8_B K0_QPB_B VSS VSS nfet_03v3 w=5.0u l=0.28u
XDGP8P_B_0 GP8_B K0_QPB_B VDD VDD pfet_03v3 w=10.0u l=0.28u
XDRP8N_B_0 RP8_B K0_QP_B VSS VSS nfet_03v3 w=5.0u l=0.28u
XDRP8P_B_0 RP8_B K0_QP_B VDD VDD pfet_03v3 w=10.0u l=0.28u
XDGN8N_B_0 GN8_B K0_QNB_B VSS VSS nfet_03v3 w=5.0u l=0.28u
XDGN8P_B_0 GN8_B K0_QNB_B VDD VDD pfet_03v3 w=10.0u l=0.28u
XDRN8N_B_0 RN8_B K0_QN_B VSS VSS nfet_03v3 w=5.0u l=0.28u
XDRN8P_B_0 RN8_B K0_QN_B VDD VDD pfet_03v3 w=10.0u l=0.28u
XK1_SNA_B_0 K1_SAB_B D0_B K1_S_m_B VSS nfet_03v3 w=5.0u l=0.28u
XK1_SNB_B_0 K1_S_m_B VALIDB_B VSS VSS nfet_03v3 w=5.0u l=0.28u
XK1_SPA_B_0 K1_SAB_B D0_B VDD VDD pfet_03v3 w=5.0u l=0.28u
XK1_SPB_B_0 K1_SAB_B VALIDB_B VDD VDD pfet_03v3 w=5.0u l=0.28u
XK1_LANA_B_0 K1_A_B K1_SAB_B K1_LA_m_B VSS nfet_03v3 w=5.0u l=0.28u
XK1_LANB_B_0 K1_LA_m_B K1_AB_B VSS VSS nfet_03v3 w=5.0u l=0.28u
XK1_LAPA_B_0 K1_A_B K1_SAB_B VDD VDD pfet_03v3 w=5.0u l=0.28u
XK1_LAPB_B_0 K1_A_B K1_AB_B VDD VDD pfet_03v3 w=5.0u l=0.28u
XK1_LBNA_B_0 K1_AB_B K1_A_B K1_LB_m_B VSS nfet_03v3 w=5.0u l=0.28u
XK1_LBNB_B_0 K1_LB_m_B RB_B VSS VSS nfet_03v3 w=5.0u l=0.28u
XK1_LBPA_B_0 K1_AB_B K1_A_B VDD VDD pfet_03v3 w=5.0u l=0.28u
XK1_LBPB_B_0 K1_AB_B RB_B VDD VDD pfet_03v3 w=5.0u l=0.28u
XK1_SPNA_B_0 K1_SETP_B K1_AB_B VSS VSS nfet_03v3 w=2.5u l=0.28u
XK1_SPNB_B_0 K1_SETP_B D1_B VSS VSS nfet_03v3 w=2.5u l=0.28u
XK1_SPNC_B_0 K1_SETP_B DPB_B VSS VSS nfet_03v3 w=2.5u l=0.28u
XK1_SPPA_B_0 K1_SP_m1_B K1_AB_B VDD VDD pfet_03v3 w=15.0u l=0.28u
XK1_SPPB_B_0 K1_SP_m2_B D1_B K1_SP_m1_B VDD pfet_03v3 w=15.0u l=0.28u
XK1_SPPC_B_0 K1_SETP_B DPB_B K1_SP_m2_B VDD pfet_03v3 w=15.0u l=0.28u
XK1_SNNA_B_0 K1_SETN_B K1_AB_B VSS VSS nfet_03v3 w=2.5u l=0.28u
XK1_SNNB_B_0 K1_SETN_B D1_B VSS VSS nfet_03v3 w=2.5u l=0.28u
XK1_SNNC_B_0 K1_SETN_B DNB_B VSS VSS nfet_03v3 w=2.5u l=0.28u
XK1_SNPA_B_0 K1_SN_m1_B K1_AB_B VDD VDD pfet_03v3 w=15.0u l=0.28u
XK1_SNPB_B_0 K1_SN_m2_B D1_B K1_SN_m1_B VDD pfet_03v3 w=15.0u l=0.28u
XK1_SNPC_B_0 K1_SETN_B DNB_B K1_SN_m2_B VDD pfet_03v3 w=15.0u l=0.28u
XK1_PANA_B_0 K1_QP_B R_B VSS VSS nfet_03v3 w=2.5u l=0.28u
XK1_PANB_B_0 K1_QP_B K1_QPB_B VSS VSS nfet_03v3 w=2.5u l=0.28u
XK1_PAPA_B_0 K1_PA_m_B R_B VDD VDD pfet_03v3 w=10.0u l=0.28u
XK1_PAPB_B_0 K1_QP_B K1_QPB_B K1_PA_m_B VDD pfet_03v3 w=10.0u l=0.28u
XK1_PBNA_B_0 K1_QPB_B K1_SETP_B VSS VSS nfet_03v3 w=2.5u l=0.28u
XK1_PBNB_B_0 K1_QPB_B K1_QP_B VSS VSS nfet_03v3 w=2.5u l=0.28u
XK1_PBPA_B_0 K1_PB_m_B K1_SETP_B VDD VDD pfet_03v3 w=10.0u l=0.28u
XK1_PBPB_B_0 K1_QPB_B K1_QP_B K1_PB_m_B VDD pfet_03v3 w=10.0u l=0.28u
XK1_NANA_B_0 K1_QN_B R_B VSS VSS nfet_03v3 w=2.5u l=0.28u
XK1_NANB_B_0 K1_QN_B K1_QNB_B VSS VSS nfet_03v3 w=2.5u l=0.28u
XK1_NAPA_B_0 K1_NA_m_B R_B VDD VDD pfet_03v3 w=10.0u l=0.28u
XK1_NAPB_B_0 K1_QN_B K1_QNB_B K1_NA_m_B VDD pfet_03v3 w=10.0u l=0.28u
XK1_NBNA_B_0 K1_QNB_B K1_SETN_B VSS VSS nfet_03v3 w=2.5u l=0.28u
XK1_NBNB_B_0 K1_QNB_B K1_QN_B VSS VSS nfet_03v3 w=2.5u l=0.28u
XK1_NBPA_B_0 K1_NB_m_B K1_SETN_B VDD VDD pfet_03v3 w=10.0u l=0.28u
XK1_NBPB_B_0 K1_QNB_B K1_QN_B K1_NB_m_B VDD pfet_03v3 w=10.0u l=0.28u
XK1_DNA_B_0 D1_B K1_QPB_B K1_D_m_B VSS nfet_03v3 w=5.0u l=0.28u
XK1_DNB_B_0 K1_D_m_B K1_QNB_B VSS VSS nfet_03v3 w=5.0u l=0.28u
XK1_DPA_B_0 D1_B K1_QPB_B VDD VDD pfet_03v3 w=5.0u l=0.28u
XK1_DPB_B_0 D1_B K1_QNB_B VDD VDD pfet_03v3 w=5.0u l=0.28u
XDRP7NA_B_0 RP7_B K1_QP_B VSS VSS nfet_03v3 w=2.5u l=0.28u
XDRP7NB_B_0 RP7_B FP_B VSS VSS nfet_03v3 w=2.5u l=0.28u
XDRP7PA_B_0 DRP7_m_B K1_QP_B VDD VDD pfet_03v3 w=10.0u l=0.28u
XDRP7PB_B_0 RP7_B FP_B DRP7_m_B VDD pfet_03v3 w=10.0u l=0.28u
XDGP7N_B_0 GP7_B RP7_B VSS VSS nfet_03v3 w=2.5u l=0.28u
XDGP7P_B_0 GP7_B RP7_B VDD VDD pfet_03v3 w=5.0u l=0.28u
XDRN7NA_B_0 RN7_B K1_QN_B VSS VSS nfet_03v3 w=2.5u l=0.28u
XDRN7NB_B_0 RN7_B FN_B VSS VSS nfet_03v3 w=2.5u l=0.28u
XDRN7PA_B_0 DRN7_m_B K1_QN_B VDD VDD pfet_03v3 w=10.0u l=0.28u
XDRN7PB_B_0 RN7_B FN_B DRN7_m_B VDD pfet_03v3 w=10.0u l=0.28u
XDGN7N_B_0 GN7_B RN7_B VSS VSS nfet_03v3 w=2.5u l=0.28u
XDGN7P_B_0 GN7_B RN7_B VDD VDD pfet_03v3 w=5.0u l=0.28u
XK2_SNA_B_0 K2_SAB_B D1_B K2_S_m_B VSS nfet_03v3 w=5.0u l=0.28u
XK2_SNB_B_0 K2_S_m_B VALIDB_B VSS VSS nfet_03v3 w=5.0u l=0.28u
XK2_SPA_B_0 K2_SAB_B D1_B VDD VDD pfet_03v3 w=5.0u l=0.28u
XK2_SPB_B_0 K2_SAB_B VALIDB_B VDD VDD pfet_03v3 w=5.0u l=0.28u
XK2_LANA_B_0 K2_A_B K2_SAB_B K2_LA_m_B VSS nfet_03v3 w=5.0u l=0.28u
XK2_LANB_B_0 K2_LA_m_B K2_AB_B VSS VSS nfet_03v3 w=5.0u l=0.28u
XK2_LAPA_B_0 K2_A_B K2_SAB_B VDD VDD pfet_03v3 w=5.0u l=0.28u
XK2_LAPB_B_0 K2_A_B K2_AB_B VDD VDD pfet_03v3 w=5.0u l=0.28u
XK2_LBNA_B_0 K2_AB_B K2_A_B K2_LB_m_B VSS nfet_03v3 w=5.0u l=0.28u
XK2_LBNB_B_0 K2_LB_m_B RB_B VSS VSS nfet_03v3 w=5.0u l=0.28u
XK2_LBPA_B_0 K2_AB_B K2_A_B VDD VDD pfet_03v3 w=5.0u l=0.28u
XK2_LBPB_B_0 K2_AB_B RB_B VDD VDD pfet_03v3 w=5.0u l=0.28u
XK2_SPNA_B_0 K2_SETP_B K2_AB_B VSS VSS nfet_03v3 w=2.5u l=0.28u
XK2_SPNB_B_0 K2_SETP_B D2_B VSS VSS nfet_03v3 w=2.5u l=0.28u
XK2_SPNC_B_0 K2_SETP_B DPB_B VSS VSS nfet_03v3 w=2.5u l=0.28u
XK2_SPPA_B_0 K2_SP_m1_B K2_AB_B VDD VDD pfet_03v3 w=15.0u l=0.28u
XK2_SPPB_B_0 K2_SP_m2_B D2_B K2_SP_m1_B VDD pfet_03v3 w=15.0u l=0.28u
XK2_SPPC_B_0 K2_SETP_B DPB_B K2_SP_m2_B VDD pfet_03v3 w=15.0u l=0.28u
XK2_SNNA_B_0 K2_SETN_B K2_AB_B VSS VSS nfet_03v3 w=2.5u l=0.28u
XK2_SNNB_B_0 K2_SETN_B D2_B VSS VSS nfet_03v3 w=2.5u l=0.28u
XK2_SNNC_B_0 K2_SETN_B DNB_B VSS VSS nfet_03v3 w=2.5u l=0.28u
XK2_SNPA_B_0 K2_SN_m1_B K2_AB_B VDD VDD pfet_03v3 w=15.0u l=0.28u
XK2_SNPB_B_0 K2_SN_m2_B D2_B K2_SN_m1_B VDD pfet_03v3 w=15.0u l=0.28u
XK2_SNPC_B_0 K2_SETN_B DNB_B K2_SN_m2_B VDD pfet_03v3 w=15.0u l=0.28u
XK2_PANA_B_0 K2_QP_B R_B VSS VSS nfet_03v3 w=2.5u l=0.28u
XK2_PANB_B_0 K2_QP_B K2_QPB_B VSS VSS nfet_03v3 w=2.5u l=0.28u
XK2_PAPA_B_0 K2_PA_m_B R_B VDD VDD pfet_03v3 w=10.0u l=0.28u
XK2_PAPB_B_0 K2_QP_B K2_QPB_B K2_PA_m_B VDD pfet_03v3 w=10.0u l=0.28u
XK2_PBNA_B_0 K2_QPB_B K2_SETP_B VSS VSS nfet_03v3 w=2.5u l=0.28u
XK2_PBNB_B_0 K2_QPB_B K2_QP_B VSS VSS nfet_03v3 w=2.5u l=0.28u
XK2_PBPA_B_0 K2_PB_m_B K2_SETP_B VDD VDD pfet_03v3 w=10.0u l=0.28u
XK2_PBPB_B_0 K2_QPB_B K2_QP_B K2_PB_m_B VDD pfet_03v3 w=10.0u l=0.28u
XK2_NANA_B_0 K2_QN_B R_B VSS VSS nfet_03v3 w=2.5u l=0.28u
XK2_NANB_B_0 K2_QN_B K2_QNB_B VSS VSS nfet_03v3 w=2.5u l=0.28u
XK2_NAPA_B_0 K2_NA_m_B R_B VDD VDD pfet_03v3 w=10.0u l=0.28u
XK2_NAPB_B_0 K2_QN_B K2_QNB_B K2_NA_m_B VDD pfet_03v3 w=10.0u l=0.28u
XK2_NBNA_B_0 K2_QNB_B K2_SETN_B VSS VSS nfet_03v3 w=2.5u l=0.28u
XK2_NBNB_B_0 K2_QNB_B K2_QN_B VSS VSS nfet_03v3 w=2.5u l=0.28u
XK2_NBPA_B_0 K2_NB_m_B K2_SETN_B VDD VDD pfet_03v3 w=10.0u l=0.28u
XK2_NBPB_B_0 K2_QNB_B K2_QN_B K2_NB_m_B VDD pfet_03v3 w=10.0u l=0.28u
XK2_DNA_B_0 D2_B K2_QPB_B K2_D_m_B VSS nfet_03v3 w=5.0u l=0.28u
XK2_DNB_B_0 K2_D_m_B K2_QNB_B VSS VSS nfet_03v3 w=5.0u l=0.28u
XK2_DPA_B_0 D2_B K2_QPB_B VDD VDD pfet_03v3 w=5.0u l=0.28u
XK2_DPB_B_0 D2_B K2_QNB_B VDD VDD pfet_03v3 w=5.0u l=0.28u
XDGP6N_B_0 GP6_B K2_QPB_B VSS VSS nfet_03v3 w=2.5u l=0.28u
XDGP6P_B_0 GP6_B K2_QPB_B VDD VDD pfet_03v3 w=5.0u l=0.28u
XDRP6N_B_0 RP6_B K2_QP_B VSS VSS nfet_03v3 w=2.5u l=0.28u
XDRP6P_B_0 RP6_B K2_QP_B VDD VDD pfet_03v3 w=5.0u l=0.28u
XDGN6N_B_0 GN6_B K2_QNB_B VSS VSS nfet_03v3 w=2.5u l=0.28u
XDGN6P_B_0 GN6_B K2_QNB_B VDD VDD pfet_03v3 w=5.0u l=0.28u
XDRN6N_B_0 RN6_B K2_QN_B VSS VSS nfet_03v3 w=2.5u l=0.28u
XDRN6P_B_0 RN6_B K2_QN_B VDD VDD pfet_03v3 w=5.0u l=0.28u
XK3_SNA_B_0 K3_SAB_B D2_B K3_S_m_B VSS nfet_03v3 w=5.0u l=0.28u
XK3_SNB_B_0 K3_S_m_B VALIDB_B VSS VSS nfet_03v3 w=5.0u l=0.28u
XK3_SPA_B_0 K3_SAB_B D2_B VDD VDD pfet_03v3 w=5.0u l=0.28u
XK3_SPB_B_0 K3_SAB_B VALIDB_B VDD VDD pfet_03v3 w=5.0u l=0.28u
XK3_LANA_B_0 K3_A_B K3_SAB_B K3_LA_m_B VSS nfet_03v3 w=5.0u l=0.28u
XK3_LANB_B_0 K3_LA_m_B K3_AB_B VSS VSS nfet_03v3 w=5.0u l=0.28u
XK3_LAPA_B_0 K3_A_B K3_SAB_B VDD VDD pfet_03v3 w=5.0u l=0.28u
XK3_LAPB_B_0 K3_A_B K3_AB_B VDD VDD pfet_03v3 w=5.0u l=0.28u
XK3_LBNA_B_0 K3_AB_B K3_A_B K3_LB_m_B VSS nfet_03v3 w=5.0u l=0.28u
XK3_LBNB_B_0 K3_LB_m_B RB_B VSS VSS nfet_03v3 w=5.0u l=0.28u
XK3_LBPA_B_0 K3_AB_B K3_A_B VDD VDD pfet_03v3 w=5.0u l=0.28u
XK3_LBPB_B_0 K3_AB_B RB_B VDD VDD pfet_03v3 w=5.0u l=0.28u
XK3_SPNA_B_0 K3_SETP_B K3_AB_B VSS VSS nfet_03v3 w=2.5u l=0.28u
XK3_SPNB_B_0 K3_SETP_B D3_B VSS VSS nfet_03v3 w=2.5u l=0.28u
XK3_SPNC_B_0 K3_SETP_B DPB_B VSS VSS nfet_03v3 w=2.5u l=0.28u
XK3_SPPA_B_0 K3_SP_m1_B K3_AB_B VDD VDD pfet_03v3 w=15.0u l=0.28u
XK3_SPPB_B_0 K3_SP_m2_B D3_B K3_SP_m1_B VDD pfet_03v3 w=15.0u l=0.28u
XK3_SPPC_B_0 K3_SETP_B DPB_B K3_SP_m2_B VDD pfet_03v3 w=15.0u l=0.28u
XK3_SNNA_B_0 K3_SETN_B K3_AB_B VSS VSS nfet_03v3 w=2.5u l=0.28u
XK3_SNNB_B_0 K3_SETN_B D3_B VSS VSS nfet_03v3 w=2.5u l=0.28u
XK3_SNNC_B_0 K3_SETN_B DNB_B VSS VSS nfet_03v3 w=2.5u l=0.28u
XK3_SNPA_B_0 K3_SN_m1_B K3_AB_B VDD VDD pfet_03v3 w=15.0u l=0.28u
XK3_SNPB_B_0 K3_SN_m2_B D3_B K3_SN_m1_B VDD pfet_03v3 w=15.0u l=0.28u
XK3_SNPC_B_0 K3_SETN_B DNB_B K3_SN_m2_B VDD pfet_03v3 w=15.0u l=0.28u
XK3_PANA_B_0 K3_QP_B R_B VSS VSS nfet_03v3 w=2.5u l=0.28u
XK3_PANB_B_0 K3_QP_B K3_QPB_B VSS VSS nfet_03v3 w=2.5u l=0.28u
XK3_PAPA_B_0 K3_PA_m_B R_B VDD VDD pfet_03v3 w=10.0u l=0.28u
XK3_PAPB_B_0 K3_QP_B K3_QPB_B K3_PA_m_B VDD pfet_03v3 w=10.0u l=0.28u
XK3_PBNA_B_0 K3_QPB_B K3_SETP_B VSS VSS nfet_03v3 w=2.5u l=0.28u
XK3_PBNB_B_0 K3_QPB_B K3_QP_B VSS VSS nfet_03v3 w=2.5u l=0.28u
XK3_PBPA_B_0 K3_PB_m_B K3_SETP_B VDD VDD pfet_03v3 w=10.0u l=0.28u
XK3_PBPB_B_0 K3_QPB_B K3_QP_B K3_PB_m_B VDD pfet_03v3 w=10.0u l=0.28u
XK3_NANA_B_0 K3_QN_B R_B VSS VSS nfet_03v3 w=2.5u l=0.28u
XK3_NANB_B_0 K3_QN_B K3_QNB_B VSS VSS nfet_03v3 w=2.5u l=0.28u
XK3_NAPA_B_0 K3_NA_m_B R_B VDD VDD pfet_03v3 w=10.0u l=0.28u
XK3_NAPB_B_0 K3_QN_B K3_QNB_B K3_NA_m_B VDD pfet_03v3 w=10.0u l=0.28u
XK3_NBNA_B_0 K3_QNB_B K3_SETN_B VSS VSS nfet_03v3 w=2.5u l=0.28u
XK3_NBNB_B_0 K3_QNB_B K3_QN_B VSS VSS nfet_03v3 w=2.5u l=0.28u
XK3_NBPA_B_0 K3_NB_m_B K3_SETN_B VDD VDD pfet_03v3 w=10.0u l=0.28u
XK3_NBPB_B_0 K3_QNB_B K3_QN_B K3_NB_m_B VDD pfet_03v3 w=10.0u l=0.28u
XK3_DNA_B_0 D3_B K3_QPB_B K3_D_m_B VSS nfet_03v3 w=5.0u l=0.28u
XK3_DNB_B_0 K3_D_m_B K3_QNB_B VSS VSS nfet_03v3 w=5.0u l=0.28u
XK3_DPA_B_0 D3_B K3_QPB_B VDD VDD pfet_03v3 w=5.0u l=0.28u
XK3_DPB_B_0 D3_B K3_QNB_B VDD VDD pfet_03v3 w=5.0u l=0.28u
XDGP5N_B_0 GP5_B K3_QPB_B VSS VSS nfet_03v3 w=5.0u l=0.28u
XDGP5P_B_0 GP5_B K3_QPB_B VDD VDD pfet_03v3 w=10.0u l=0.28u
XDRP5N_B_0 RP5_B K3_QP_B VSS VSS nfet_03v3 w=5.0u l=0.28u
XDRP5P_B_0 RP5_B K3_QP_B VDD VDD pfet_03v3 w=10.0u l=0.28u
XDGN5N_B_0 GN5_B K3_QNB_B VSS VSS nfet_03v3 w=5.0u l=0.28u
XDGN5P_B_0 GN5_B K3_QNB_B VDD VDD pfet_03v3 w=10.0u l=0.28u
XDRN5N_B_0 RN5_B K3_QN_B VSS VSS nfet_03v3 w=5.0u l=0.28u
XDRN5P_B_0 RN5_B K3_QN_B VDD VDD pfet_03v3 w=10.0u l=0.28u
XK4_SNA_B_0 K4_SAB_B D3_B K4_S_m_B VSS nfet_03v3 w=5.0u l=0.28u
XK4_SNB_B_0 K4_S_m_B VALIDB_B VSS VSS nfet_03v3 w=5.0u l=0.28u
XK4_SPA_B_0 K4_SAB_B D3_B VDD VDD pfet_03v3 w=5.0u l=0.28u
XK4_SPB_B_0 K4_SAB_B VALIDB_B VDD VDD pfet_03v3 w=5.0u l=0.28u
XK4_LANA_B_0 K4_A_B K4_SAB_B K4_LA_m_B VSS nfet_03v3 w=5.0u l=0.28u
XK4_LANB_B_0 K4_LA_m_B K4_AB_B VSS VSS nfet_03v3 w=5.0u l=0.28u
XK4_LAPA_B_0 K4_A_B K4_SAB_B VDD VDD pfet_03v3 w=5.0u l=0.28u
XK4_LAPB_B_0 K4_A_B K4_AB_B VDD VDD pfet_03v3 w=5.0u l=0.28u
XK4_LBNA_B_0 K4_AB_B K4_A_B K4_LB_m_B VSS nfet_03v3 w=5.0u l=0.28u
XK4_LBNB_B_0 K4_LB_m_B RB_B VSS VSS nfet_03v3 w=5.0u l=0.28u
XK4_LBPA_B_0 K4_AB_B K4_A_B VDD VDD pfet_03v3 w=5.0u l=0.28u
XK4_LBPB_B_0 K4_AB_B RB_B VDD VDD pfet_03v3 w=5.0u l=0.28u
XK4_SPNA_B_0 K4_SETP_B K4_AB_B VSS VSS nfet_03v3 w=2.5u l=0.28u
XK4_SPNB_B_0 K4_SETP_B D4_B VSS VSS nfet_03v3 w=2.5u l=0.28u
XK4_SPNC_B_0 K4_SETP_B DPB_B VSS VSS nfet_03v3 w=2.5u l=0.28u
XK4_SPPA_B_0 K4_SP_m1_B K4_AB_B VDD VDD pfet_03v3 w=15.0u l=0.28u
XK4_SPPB_B_0 K4_SP_m2_B D4_B K4_SP_m1_B VDD pfet_03v3 w=15.0u l=0.28u
XK4_SPPC_B_0 K4_SETP_B DPB_B K4_SP_m2_B VDD pfet_03v3 w=15.0u l=0.28u
XK4_SNNA_B_0 K4_SETN_B K4_AB_B VSS VSS nfet_03v3 w=2.5u l=0.28u
XK4_SNNB_B_0 K4_SETN_B D4_B VSS VSS nfet_03v3 w=2.5u l=0.28u
XK4_SNNC_B_0 K4_SETN_B DNB_B VSS VSS nfet_03v3 w=2.5u l=0.28u
XK4_SNPA_B_0 K4_SN_m1_B K4_AB_B VDD VDD pfet_03v3 w=15.0u l=0.28u
XK4_SNPB_B_0 K4_SN_m2_B D4_B K4_SN_m1_B VDD pfet_03v3 w=15.0u l=0.28u
XK4_SNPC_B_0 K4_SETN_B DNB_B K4_SN_m2_B VDD pfet_03v3 w=15.0u l=0.28u
XK4_PANA_B_0 K4_QP_B R_B VSS VSS nfet_03v3 w=2.5u l=0.28u
XK4_PANB_B_0 K4_QP_B K4_QPB_B VSS VSS nfet_03v3 w=2.5u l=0.28u
XK4_PAPA_B_0 K4_PA_m_B R_B VDD VDD pfet_03v3 w=10.0u l=0.28u
XK4_PAPB_B_0 K4_QP_B K4_QPB_B K4_PA_m_B VDD pfet_03v3 w=10.0u l=0.28u
XK4_PBNA_B_0 K4_QPB_B K4_SETP_B VSS VSS nfet_03v3 w=2.5u l=0.28u
XK4_PBNB_B_0 K4_QPB_B K4_QP_B VSS VSS nfet_03v3 w=2.5u l=0.28u
XK4_PBPA_B_0 K4_PB_m_B K4_SETP_B VDD VDD pfet_03v3 w=10.0u l=0.28u
XK4_PBPB_B_0 K4_QPB_B K4_QP_B K4_PB_m_B VDD pfet_03v3 w=10.0u l=0.28u
XK4_NANA_B_0 K4_QN_B R_B VSS VSS nfet_03v3 w=2.5u l=0.28u
XK4_NANB_B_0 K4_QN_B K4_QNB_B VSS VSS nfet_03v3 w=2.5u l=0.28u
XK4_NAPA_B_0 K4_NA_m_B R_B VDD VDD pfet_03v3 w=10.0u l=0.28u
XK4_NAPB_B_0 K4_QN_B K4_QNB_B K4_NA_m_B VDD pfet_03v3 w=10.0u l=0.28u
XK4_NBNA_B_0 K4_QNB_B K4_SETN_B VSS VSS nfet_03v3 w=2.5u l=0.28u
XK4_NBNB_B_0 K4_QNB_B K4_QN_B VSS VSS nfet_03v3 w=2.5u l=0.28u
XK4_NBPA_B_0 K4_NB_m_B K4_SETN_B VDD VDD pfet_03v3 w=10.0u l=0.28u
XK4_NBPB_B_0 K4_QNB_B K4_QN_B K4_NB_m_B VDD pfet_03v3 w=10.0u l=0.28u
XK4_DNA_B_0 D4_B K4_QPB_B K4_D_m_B VSS nfet_03v3 w=5.0u l=0.28u
XK4_DNB_B_0 K4_D_m_B K4_QNB_B VSS VSS nfet_03v3 w=5.0u l=0.28u
XK4_DPA_B_0 D4_B K4_QPB_B VDD VDD pfet_03v3 w=5.0u l=0.28u
XK4_DPB_B_0 D4_B K4_QNB_B VDD VDD pfet_03v3 w=5.0u l=0.28u
XDGP4N_B_0 GP4_B K4_QPB_B VSS VSS nfet_03v3 w=5.0u l=0.28u
XDGP4P_B_0 GP4_B K4_QPB_B VDD VDD pfet_03v3 w=10.0u l=0.28u
XDRP4N_B_0 RP4_B K4_QP_B VSS VSS nfet_03v3 w=5.0u l=0.28u
XDRP4P_B_0 RP4_B K4_QP_B VDD VDD pfet_03v3 w=10.0u l=0.28u
XDGN4N_B_0 GN4_B K4_QNB_B VSS VSS nfet_03v3 w=5.0u l=0.28u
XDGN4P_B_0 GN4_B K4_QNB_B VDD VDD pfet_03v3 w=10.0u l=0.28u
XDRN4N_B_0 RN4_B K4_QN_B VSS VSS nfet_03v3 w=5.0u l=0.28u
XDRN4P_B_0 RN4_B K4_QN_B VDD VDD pfet_03v3 w=10.0u l=0.28u
XK5_SNA_B_0 K5_SAB_B D4_B K5_S_m_B VSS nfet_03v3 w=5.0u l=0.28u
XK5_SNB_B_0 K5_S_m_B VALIDB_B VSS VSS nfet_03v3 w=5.0u l=0.28u
XK5_SPA_B_0 K5_SAB_B D4_B VDD VDD pfet_03v3 w=5.0u l=0.28u
XK5_SPB_B_0 K5_SAB_B VALIDB_B VDD VDD pfet_03v3 w=5.0u l=0.28u
XK5_LANA_B_0 K5_A_B K5_SAB_B K5_LA_m_B VSS nfet_03v3 w=5.0u l=0.28u
XK5_LANB_B_0 K5_LA_m_B K5_AB_B VSS VSS nfet_03v3 w=5.0u l=0.28u
XK5_LAPA_B_0 K5_A_B K5_SAB_B VDD VDD pfet_03v3 w=5.0u l=0.28u
XK5_LAPB_B_0 K5_A_B K5_AB_B VDD VDD pfet_03v3 w=5.0u l=0.28u
XK5_LBNA_B_0 K5_AB_B K5_A_B K5_LB_m_B VSS nfet_03v3 w=5.0u l=0.28u
XK5_LBNB_B_0 K5_LB_m_B RB_B VSS VSS nfet_03v3 w=5.0u l=0.28u
XK5_LBPA_B_0 K5_AB_B K5_A_B VDD VDD pfet_03v3 w=5.0u l=0.28u
XK5_LBPB_B_0 K5_AB_B RB_B VDD VDD pfet_03v3 w=5.0u l=0.28u
XK5_SPNA_B_0 K5_SETP_B K5_AB_B VSS VSS nfet_03v3 w=2.5u l=0.28u
XK5_SPNB_B_0 K5_SETP_B D5_B VSS VSS nfet_03v3 w=2.5u l=0.28u
XK5_SPNC_B_0 K5_SETP_B DPB_B VSS VSS nfet_03v3 w=2.5u l=0.28u
XK5_SPPA_B_0 K5_SP_m1_B K5_AB_B VDD VDD pfet_03v3 w=15.0u l=0.28u
XK5_SPPB_B_0 K5_SP_m2_B D5_B K5_SP_m1_B VDD pfet_03v3 w=15.0u l=0.28u
XK5_SPPC_B_0 K5_SETP_B DPB_B K5_SP_m2_B VDD pfet_03v3 w=15.0u l=0.28u
XK5_SNNA_B_0 K5_SETN_B K5_AB_B VSS VSS nfet_03v3 w=2.5u l=0.28u
XK5_SNNB_B_0 K5_SETN_B D5_B VSS VSS nfet_03v3 w=2.5u l=0.28u
XK5_SNNC_B_0 K5_SETN_B DNB_B VSS VSS nfet_03v3 w=2.5u l=0.28u
XK5_SNPA_B_0 K5_SN_m1_B K5_AB_B VDD VDD pfet_03v3 w=15.0u l=0.28u
XK5_SNPB_B_0 K5_SN_m2_B D5_B K5_SN_m1_B VDD pfet_03v3 w=15.0u l=0.28u
XK5_SNPC_B_0 K5_SETN_B DNB_B K5_SN_m2_B VDD pfet_03v3 w=15.0u l=0.28u
XK5_PANA_B_0 K5_QP_B R_B VSS VSS nfet_03v3 w=2.5u l=0.28u
XK5_PANB_B_0 K5_QP_B K5_QPB_B VSS VSS nfet_03v3 w=2.5u l=0.28u
XK5_PAPA_B_0 K5_PA_m_B R_B VDD VDD pfet_03v3 w=10.0u l=0.28u
XK5_PAPB_B_0 K5_QP_B K5_QPB_B K5_PA_m_B VDD pfet_03v3 w=10.0u l=0.28u
XK5_PBNA_B_0 K5_QPB_B K5_SETP_B VSS VSS nfet_03v3 w=2.5u l=0.28u
XK5_PBNB_B_0 K5_QPB_B K5_QP_B VSS VSS nfet_03v3 w=2.5u l=0.28u
XK5_PBPA_B_0 K5_PB_m_B K5_SETP_B VDD VDD pfet_03v3 w=10.0u l=0.28u
XK5_PBPB_B_0 K5_QPB_B K5_QP_B K5_PB_m_B VDD pfet_03v3 w=10.0u l=0.28u
XK5_NANA_B_0 K5_QN_B R_B VSS VSS nfet_03v3 w=2.5u l=0.28u
XK5_NANB_B_0 K5_QN_B K5_QNB_B VSS VSS nfet_03v3 w=2.5u l=0.28u
XK5_NAPA_B_0 K5_NA_m_B R_B VDD VDD pfet_03v3 w=10.0u l=0.28u
XK5_NAPB_B_0 K5_QN_B K5_QNB_B K5_NA_m_B VDD pfet_03v3 w=10.0u l=0.28u
XK5_NBNA_B_0 K5_QNB_B K5_SETN_B VSS VSS nfet_03v3 w=2.5u l=0.28u
XK5_NBNB_B_0 K5_QNB_B K5_QN_B VSS VSS nfet_03v3 w=2.5u l=0.28u
XK5_NBPA_B_0 K5_NB_m_B K5_SETN_B VDD VDD pfet_03v3 w=10.0u l=0.28u
XK5_NBPB_B_0 K5_QNB_B K5_QN_B K5_NB_m_B VDD pfet_03v3 w=10.0u l=0.28u
XK5_DNA_B_0 D5_B K5_QPB_B K5_D_m_B VSS nfet_03v3 w=5.0u l=0.28u
XK5_DNB_B_0 K5_D_m_B K5_QNB_B VSS VSS nfet_03v3 w=5.0u l=0.28u
XK5_DPA_B_0 D5_B K5_QPB_B VDD VDD pfet_03v3 w=5.0u l=0.28u
XK5_DPB_B_0 D5_B K5_QNB_B VDD VDD pfet_03v3 w=5.0u l=0.28u
XDGP3N_B_0 GP3_B K5_QPB_B VSS VSS nfet_03v3 w=2.5u l=0.28u
XDGP3P_B_0 GP3_B K5_QPB_B VDD VDD pfet_03v3 w=5.0u l=0.28u
XDRP3N_B_0 RP3_B K5_QP_B VSS VSS nfet_03v3 w=2.5u l=0.28u
XDRP3P_B_0 RP3_B K5_QP_B VDD VDD pfet_03v3 w=5.0u l=0.28u
XDGN3N_B_0 GN3_B K5_QNB_B VSS VSS nfet_03v3 w=2.5u l=0.28u
XDGN3P_B_0 GN3_B K5_QNB_B VDD VDD pfet_03v3 w=5.0u l=0.28u
XDRN3N_B_0 RN3_B K5_QN_B VSS VSS nfet_03v3 w=2.5u l=0.28u
XDRN3P_B_0 RN3_B K5_QN_B VDD VDD pfet_03v3 w=5.0u l=0.28u
XK6_SNA_B_0 K6_SAB_B D5_B K6_S_m_B VSS nfet_03v3 w=5.0u l=0.28u
XK6_SNB_B_0 K6_S_m_B VALIDB_B VSS VSS nfet_03v3 w=5.0u l=0.28u
XK6_SPA_B_0 K6_SAB_B D5_B VDD VDD pfet_03v3 w=5.0u l=0.28u
XK6_SPB_B_0 K6_SAB_B VALIDB_B VDD VDD pfet_03v3 w=5.0u l=0.28u
XK6_LANA_B_0 K6_A_B K6_SAB_B K6_LA_m_B VSS nfet_03v3 w=5.0u l=0.28u
XK6_LANB_B_0 K6_LA_m_B K6_AB_B VSS VSS nfet_03v3 w=5.0u l=0.28u
XK6_LAPA_B_0 K6_A_B K6_SAB_B VDD VDD pfet_03v3 w=5.0u l=0.28u
XK6_LAPB_B_0 K6_A_B K6_AB_B VDD VDD pfet_03v3 w=5.0u l=0.28u
XK6_LBNA_B_0 K6_AB_B K6_A_B K6_LB_m_B VSS nfet_03v3 w=5.0u l=0.28u
XK6_LBNB_B_0 K6_LB_m_B RB_B VSS VSS nfet_03v3 w=5.0u l=0.28u
XK6_LBPA_B_0 K6_AB_B K6_A_B VDD VDD pfet_03v3 w=5.0u l=0.28u
XK6_LBPB_B_0 K6_AB_B RB_B VDD VDD pfet_03v3 w=5.0u l=0.28u
XK6_SPNA_B_0 K6_SETP_B K6_AB_B VSS VSS nfet_03v3 w=2.5u l=0.28u
XK6_SPNB_B_0 K6_SETP_B D6_B VSS VSS nfet_03v3 w=2.5u l=0.28u
XK6_SPNC_B_0 K6_SETP_B DPB_B VSS VSS nfet_03v3 w=2.5u l=0.28u
XK6_SPPA_B_0 K6_SP_m1_B K6_AB_B VDD VDD pfet_03v3 w=15.0u l=0.28u
XK6_SPPB_B_0 K6_SP_m2_B D6_B K6_SP_m1_B VDD pfet_03v3 w=15.0u l=0.28u
XK6_SPPC_B_0 K6_SETP_B DPB_B K6_SP_m2_B VDD pfet_03v3 w=15.0u l=0.28u
XK6_SNNA_B_0 K6_SETN_B K6_AB_B VSS VSS nfet_03v3 w=2.5u l=0.28u
XK6_SNNB_B_0 K6_SETN_B D6_B VSS VSS nfet_03v3 w=2.5u l=0.28u
XK6_SNNC_B_0 K6_SETN_B DNB_B VSS VSS nfet_03v3 w=2.5u l=0.28u
XK6_SNPA_B_0 K6_SN_m1_B K6_AB_B VDD VDD pfet_03v3 w=15.0u l=0.28u
XK6_SNPB_B_0 K6_SN_m2_B D6_B K6_SN_m1_B VDD pfet_03v3 w=15.0u l=0.28u
XK6_SNPC_B_0 K6_SETN_B DNB_B K6_SN_m2_B VDD pfet_03v3 w=15.0u l=0.28u
XK6_PANA_B_0 K6_QP_B R_B VSS VSS nfet_03v3 w=2.5u l=0.28u
XK6_PANB_B_0 K6_QP_B K6_QPB_B VSS VSS nfet_03v3 w=2.5u l=0.28u
XK6_PAPA_B_0 K6_PA_m_B R_B VDD VDD pfet_03v3 w=10.0u l=0.28u
XK6_PAPB_B_0 K6_QP_B K6_QPB_B K6_PA_m_B VDD pfet_03v3 w=10.0u l=0.28u
XK6_PBNA_B_0 K6_QPB_B K6_SETP_B VSS VSS nfet_03v3 w=2.5u l=0.28u
XK6_PBNB_B_0 K6_QPB_B K6_QP_B VSS VSS nfet_03v3 w=2.5u l=0.28u
XK6_PBPA_B_0 K6_PB_m_B K6_SETP_B VDD VDD pfet_03v3 w=10.0u l=0.28u
XK6_PBPB_B_0 K6_QPB_B K6_QP_B K6_PB_m_B VDD pfet_03v3 w=10.0u l=0.28u
XK6_NANA_B_0 K6_QN_B R_B VSS VSS nfet_03v3 w=2.5u l=0.28u
XK6_NANB_B_0 K6_QN_B K6_QNB_B VSS VSS nfet_03v3 w=2.5u l=0.28u
XK6_NAPA_B_0 K6_NA_m_B R_B VDD VDD pfet_03v3 w=10.0u l=0.28u
XK6_NAPB_B_0 K6_QN_B K6_QNB_B K6_NA_m_B VDD pfet_03v3 w=10.0u l=0.28u
XK6_NBNA_B_0 K6_QNB_B K6_SETN_B VSS VSS nfet_03v3 w=2.5u l=0.28u
XK6_NBNB_B_0 K6_QNB_B K6_QN_B VSS VSS nfet_03v3 w=2.5u l=0.28u
XK6_NBPA_B_0 K6_NB_m_B K6_SETN_B VDD VDD pfet_03v3 w=10.0u l=0.28u
XK6_NBPB_B_0 K6_QNB_B K6_QN_B K6_NB_m_B VDD pfet_03v3 w=10.0u l=0.28u
XK6_DNA_B_0 D6_B K6_QPB_B K6_D_m_B VSS nfet_03v3 w=5.0u l=0.28u
XK6_DNB_B_0 K6_D_m_B K6_QNB_B VSS VSS nfet_03v3 w=5.0u l=0.28u
XK6_DPA_B_0 D6_B K6_QPB_B VDD VDD pfet_03v3 w=5.0u l=0.28u
XK6_DPB_B_0 D6_B K6_QNB_B VDD VDD pfet_03v3 w=5.0u l=0.28u
XDGP2N_B_0 GP2_B K6_QPB_B VSS VSS nfet_03v3 w=2.5u l=0.28u
XDGP2P_B_0 GP2_B K6_QPB_B VDD VDD pfet_03v3 w=5.0u l=0.28u
XDRP2N_B_0 RP2_B K6_QP_B VSS VSS nfet_03v3 w=2.5u l=0.28u
XDRP2P_B_0 RP2_B K6_QP_B VDD VDD pfet_03v3 w=5.0u l=0.28u
XDGN2N_B_0 GN2_B K6_QNB_B VSS VSS nfet_03v3 w=2.5u l=0.28u
XDGN2P_B_0 GN2_B K6_QNB_B VDD VDD pfet_03v3 w=5.0u l=0.28u
XDRN2N_B_0 RN2_B K6_QN_B VSS VSS nfet_03v3 w=2.5u l=0.28u
XDRN2P_B_0 RN2_B K6_QN_B VDD VDD pfet_03v3 w=5.0u l=0.28u
XK7_SNA_B_0 K7_SAB_B D6_B K7_S_m_B VSS nfet_03v3 w=5.0u l=0.28u
XK7_SNB_B_0 K7_S_m_B VALIDB_B VSS VSS nfet_03v3 w=5.0u l=0.28u
XK7_SPA_B_0 K7_SAB_B D6_B VDD VDD pfet_03v3 w=5.0u l=0.28u
XK7_SPB_B_0 K7_SAB_B VALIDB_B VDD VDD pfet_03v3 w=5.0u l=0.28u
XK7_LANA_B_0 K7_A_B K7_SAB_B K7_LA_m_B VSS nfet_03v3 w=5.0u l=0.28u
XK7_LANB_B_0 K7_LA_m_B K7_AB_B VSS VSS nfet_03v3 w=5.0u l=0.28u
XK7_LAPA_B_0 K7_A_B K7_SAB_B VDD VDD pfet_03v3 w=5.0u l=0.28u
XK7_LAPB_B_0 K7_A_B K7_AB_B VDD VDD pfet_03v3 w=5.0u l=0.28u
XK7_LBNA_B_0 K7_AB_B K7_A_B K7_LB_m_B VSS nfet_03v3 w=5.0u l=0.28u
XK7_LBNB_B_0 K7_LB_m_B RB_B VSS VSS nfet_03v3 w=5.0u l=0.28u
XK7_LBPA_B_0 K7_AB_B K7_A_B VDD VDD pfet_03v3 w=5.0u l=0.28u
XK7_LBPB_B_0 K7_AB_B RB_B VDD VDD pfet_03v3 w=5.0u l=0.28u
XK7_SPNA_B_0 K7_SETP_B K7_AB_B VSS VSS nfet_03v3 w=2.5u l=0.28u
XK7_SPNB_B_0 K7_SETP_B D7_B VSS VSS nfet_03v3 w=2.5u l=0.28u
XK7_SPNC_B_0 K7_SETP_B DPB_B VSS VSS nfet_03v3 w=2.5u l=0.28u
XK7_SPPA_B_0 K7_SP_m1_B K7_AB_B VDD VDD pfet_03v3 w=15.0u l=0.28u
XK7_SPPB_B_0 K7_SP_m2_B D7_B K7_SP_m1_B VDD pfet_03v3 w=15.0u l=0.28u
XK7_SPPC_B_0 K7_SETP_B DPB_B K7_SP_m2_B VDD pfet_03v3 w=15.0u l=0.28u
XK7_SNNA_B_0 K7_SETN_B K7_AB_B VSS VSS nfet_03v3 w=2.5u l=0.28u
XK7_SNNB_B_0 K7_SETN_B D7_B VSS VSS nfet_03v3 w=2.5u l=0.28u
XK7_SNNC_B_0 K7_SETN_B DNB_B VSS VSS nfet_03v3 w=2.5u l=0.28u
XK7_SNPA_B_0 K7_SN_m1_B K7_AB_B VDD VDD pfet_03v3 w=15.0u l=0.28u
XK7_SNPB_B_0 K7_SN_m2_B D7_B K7_SN_m1_B VDD pfet_03v3 w=15.0u l=0.28u
XK7_SNPC_B_0 K7_SETN_B DNB_B K7_SN_m2_B VDD pfet_03v3 w=15.0u l=0.28u
XK7_PANA_B_0 K7_QP_B R_B VSS VSS nfet_03v3 w=2.5u l=0.28u
XK7_PANB_B_0 K7_QP_B K7_QPB_B VSS VSS nfet_03v3 w=2.5u l=0.28u
XK7_PAPA_B_0 K7_PA_m_B R_B VDD VDD pfet_03v3 w=10.0u l=0.28u
XK7_PAPB_B_0 K7_QP_B K7_QPB_B K7_PA_m_B VDD pfet_03v3 w=10.0u l=0.28u
XK7_PBNA_B_0 K7_QPB_B K7_SETP_B VSS VSS nfet_03v3 w=2.5u l=0.28u
XK7_PBNB_B_0 K7_QPB_B K7_QP_B VSS VSS nfet_03v3 w=2.5u l=0.28u
XK7_PBPA_B_0 K7_PB_m_B K7_SETP_B VDD VDD pfet_03v3 w=10.0u l=0.28u
XK7_PBPB_B_0 K7_QPB_B K7_QP_B K7_PB_m_B VDD pfet_03v3 w=10.0u l=0.28u
XK7_NANA_B_0 K7_QN_B R_B VSS VSS nfet_03v3 w=2.5u l=0.28u
XK7_NANB_B_0 K7_QN_B K7_QNB_B VSS VSS nfet_03v3 w=2.5u l=0.28u
XK7_NAPA_B_0 K7_NA_m_B R_B VDD VDD pfet_03v3 w=10.0u l=0.28u
XK7_NAPB_B_0 K7_QN_B K7_QNB_B K7_NA_m_B VDD pfet_03v3 w=10.0u l=0.28u
XK7_NBNA_B_0 K7_QNB_B K7_SETN_B VSS VSS nfet_03v3 w=2.5u l=0.28u
XK7_NBNB_B_0 K7_QNB_B K7_QN_B VSS VSS nfet_03v3 w=2.5u l=0.28u
XK7_NBPA_B_0 K7_NB_m_B K7_SETN_B VDD VDD pfet_03v3 w=10.0u l=0.28u
XK7_NBPB_B_0 K7_QNB_B K7_QN_B K7_NB_m_B VDD pfet_03v3 w=10.0u l=0.28u
XK7_DNA_B_0 D7_B K7_QPB_B K7_D_m_B VSS nfet_03v3 w=5.0u l=0.28u
XK7_DNB_B_0 K7_D_m_B K7_QNB_B VSS VSS nfet_03v3 w=5.0u l=0.28u
XK7_DPA_B_0 D7_B K7_QPB_B VDD VDD pfet_03v3 w=5.0u l=0.28u
XK7_DPB_B_0 D7_B K7_QNB_B VDD VDD pfet_03v3 w=5.0u l=0.28u
XDGP1N_B_0 GP1_B K7_QPB_B VSS VSS nfet_03v3 w=2.5u l=0.28u
XDGP1P_B_0 GP1_B K7_QPB_B VDD VDD pfet_03v3 w=5.0u l=0.28u
XDRP1N_B_0 RP1_B K7_QP_B VSS VSS nfet_03v3 w=2.5u l=0.28u
XDRP1P_B_0 RP1_B K7_QP_B VDD VDD pfet_03v3 w=5.0u l=0.28u
XDGN1N_B_0 GN1_B K7_QNB_B VSS VSS nfet_03v3 w=2.5u l=0.28u
XDGN1P_B_0 GN1_B K7_QNB_B VDD VDD pfet_03v3 w=5.0u l=0.28u
XDRN1N_B_0 RN1_B K7_QN_B VSS VSS nfet_03v3 w=2.5u l=0.28u
XDRN1P_B_0 RN1_B K7_QN_B VDD VDD pfet_03v3 w=5.0u l=0.28u
XK8_SNA_B_0 K8_SAB_B D7_B K8_S_m_B VSS nfet_03v3 w=5.0u l=0.28u
XK8_SNB_B_0 K8_S_m_B VALIDB_B VSS VSS nfet_03v3 w=5.0u l=0.28u
XK8_SPA_B_0 K8_SAB_B D7_B VDD VDD pfet_03v3 w=5.0u l=0.28u
XK8_SPB_B_0 K8_SAB_B VALIDB_B VDD VDD pfet_03v3 w=5.0u l=0.28u
XK8_LANA_B_0 K8_A_B K8_SAB_B K8_LA_m_B VSS nfet_03v3 w=5.0u l=0.28u
XK8_LANB_B_0 K8_LA_m_B K8_AB_B VSS VSS nfet_03v3 w=5.0u l=0.28u
XK8_LAPA_B_0 K8_A_B K8_SAB_B VDD VDD pfet_03v3 w=5.0u l=0.28u
XK8_LAPB_B_0 K8_A_B K8_AB_B VDD VDD pfet_03v3 w=5.0u l=0.28u
XK8_LBNA_B_0 K8_AB_B K8_A_B K8_LB_m_B VSS nfet_03v3 w=5.0u l=0.28u
XK8_LBNB_B_0 K8_LB_m_B RB_B VSS VSS nfet_03v3 w=5.0u l=0.28u
XK8_LBPA_B_0 K8_AB_B K8_A_B VDD VDD pfet_03v3 w=5.0u l=0.28u
XK8_LBPB_B_0 K8_AB_B RB_B VDD VDD pfet_03v3 w=5.0u l=0.28u
XK8_SPNA_B_0 K8_SETP_B K8_AB_B VSS VSS nfet_03v3 w=2.5u l=0.28u
XK8_SPNB_B_0 K8_SETP_B D8_B VSS VSS nfet_03v3 w=2.5u l=0.28u
XK8_SPNC_B_0 K8_SETP_B DPB_B VSS VSS nfet_03v3 w=2.5u l=0.28u
XK8_SPPA_B_0 K8_SP_m1_B K8_AB_B VDD VDD pfet_03v3 w=15.0u l=0.28u
XK8_SPPB_B_0 K8_SP_m2_B D8_B K8_SP_m1_B VDD pfet_03v3 w=15.0u l=0.28u
XK8_SPPC_B_0 K8_SETP_B DPB_B K8_SP_m2_B VDD pfet_03v3 w=15.0u l=0.28u
XK8_SNNA_B_0 K8_SETN_B K8_AB_B VSS VSS nfet_03v3 w=2.5u l=0.28u
XK8_SNNB_B_0 K8_SETN_B D8_B VSS VSS nfet_03v3 w=2.5u l=0.28u
XK8_SNNC_B_0 K8_SETN_B DNB_B VSS VSS nfet_03v3 w=2.5u l=0.28u
XK8_SNPA_B_0 K8_SN_m1_B K8_AB_B VDD VDD pfet_03v3 w=15.0u l=0.28u
XK8_SNPB_B_0 K8_SN_m2_B D8_B K8_SN_m1_B VDD pfet_03v3 w=15.0u l=0.28u
XK8_SNPC_B_0 K8_SETN_B DNB_B K8_SN_m2_B VDD pfet_03v3 w=15.0u l=0.28u
XK8_PANA_B_0 K8_QP_B R_B VSS VSS nfet_03v3 w=2.5u l=0.28u
XK8_PANB_B_0 K8_QP_B K8_QPB_B VSS VSS nfet_03v3 w=2.5u l=0.28u
XK8_PAPA_B_0 K8_PA_m_B R_B VDD VDD pfet_03v3 w=10.0u l=0.28u
XK8_PAPB_B_0 K8_QP_B K8_QPB_B K8_PA_m_B VDD pfet_03v3 w=10.0u l=0.28u
XK8_PBNA_B_0 K8_QPB_B K8_SETP_B VSS VSS nfet_03v3 w=2.5u l=0.28u
XK8_PBNB_B_0 K8_QPB_B K8_QP_B VSS VSS nfet_03v3 w=2.5u l=0.28u
XK8_PBPA_B_0 K8_PB_m_B K8_SETP_B VDD VDD pfet_03v3 w=10.0u l=0.28u
XK8_PBPB_B_0 K8_QPB_B K8_QP_B K8_PB_m_B VDD pfet_03v3 w=10.0u l=0.28u
XK8_NANA_B_0 K8_QN_B R_B VSS VSS nfet_03v3 w=2.5u l=0.28u
XK8_NANB_B_0 K8_QN_B K8_QNB_B VSS VSS nfet_03v3 w=2.5u l=0.28u
XK8_NAPA_B_0 K8_NA_m_B R_B VDD VDD pfet_03v3 w=10.0u l=0.28u
XK8_NAPB_B_0 K8_QN_B K8_QNB_B K8_NA_m_B VDD pfet_03v3 w=10.0u l=0.28u
XK8_NBNA_B_0 K8_QNB_B K8_SETN_B VSS VSS nfet_03v3 w=2.5u l=0.28u
XK8_NBNB_B_0 K8_QNB_B K8_QN_B VSS VSS nfet_03v3 w=2.5u l=0.28u
XK8_NBPA_B_0 K8_NB_m_B K8_SETN_B VDD VDD pfet_03v3 w=10.0u l=0.28u
XK8_NBPB_B_0 K8_QNB_B K8_QN_B K8_NB_m_B VDD pfet_03v3 w=10.0u l=0.28u
XK8_DNA_B_0 D8_B K8_QPB_B K8_D_m_B VSS nfet_03v3 w=5.0u l=0.28u
XK8_DNB_B_0 K8_D_m_B K8_QNB_B VSS VSS nfet_03v3 w=5.0u l=0.28u
XK8_DPA_B_0 D8_B K8_QPB_B VDD VDD pfet_03v3 w=5.0u l=0.28u
XK8_DPB_B_0 D8_B K8_QNB_B VDD VDD pfet_03v3 w=5.0u l=0.28u
XDGP0N_B_0 GP0_B K8_QPB_B VSS VSS nfet_03v3 w=2.5u l=0.28u
XDGP0P_B_0 GP0_B K8_QPB_B VDD VDD pfet_03v3 w=5.0u l=0.28u
XDRP0N_B_0 RP0_B K8_QP_B VSS VSS nfet_03v3 w=2.5u l=0.28u
XDRP0P_B_0 RP0_B K8_QP_B VDD VDD pfet_03v3 w=5.0u l=0.28u
XDGN0N_B_0 GN0_B K8_QNB_B VSS VSS nfet_03v3 w=2.5u l=0.28u
XDGN0P_B_0 GN0_B K8_QNB_B VDD VDD pfet_03v3 w=5.0u l=0.28u
XDRN0N_B_0 RN0_B K8_QN_B VSS VSS nfet_03v3 w=2.5u l=0.28u
XDRN0P_B_0 RN0_B K8_QN_B VDD VDD pfet_03v3 w=5.0u l=0.28u
XK9_SNA_B_0 K9_SAB_B D8_B K9_S_m_B VSS nfet_03v3 w=5.0u l=0.28u
XK9_SNB_B_0 K9_S_m_B VALIDB_B VSS VSS nfet_03v3 w=5.0u l=0.28u
XK9_SPA_B_0 K9_SAB_B D8_B VDD VDD pfet_03v3 w=5.0u l=0.28u
XK9_SPB_B_0 K9_SAB_B VALIDB_B VDD VDD pfet_03v3 w=5.0u l=0.28u
XK9_LANA_B_0 K9_A_B K9_SAB_B K9_LA_m_B VSS nfet_03v3 w=5.0u l=0.28u
XK9_LANB_B_0 K9_LA_m_B K9_AB_B VSS VSS nfet_03v3 w=5.0u l=0.28u
XK9_LAPA_B_0 K9_A_B K9_SAB_B VDD VDD pfet_03v3 w=5.0u l=0.28u
XK9_LAPB_B_0 K9_A_B K9_AB_B VDD VDD pfet_03v3 w=5.0u l=0.28u
XK9_LBNA_B_0 K9_AB_B K9_A_B K9_LB_m_B VSS nfet_03v3 w=5.0u l=0.28u
XK9_LBNB_B_0 K9_LB_m_B RB_B VSS VSS nfet_03v3 w=5.0u l=0.28u
XK9_LBPA_B_0 K9_AB_B K9_A_B VDD VDD pfet_03v3 w=5.0u l=0.28u
XK9_LBPB_B_0 K9_AB_B RB_B VDD VDD pfet_03v3 w=5.0u l=0.28u
XK9_SPNA_B_0 K9_SETP_B K9_AB_B VSS VSS nfet_03v3 w=2.5u l=0.28u
XK9_SPNB_B_0 K9_SETP_B D9_B VSS VSS nfet_03v3 w=2.5u l=0.28u
XK9_SPNC_B_0 K9_SETP_B DPB_B VSS VSS nfet_03v3 w=2.5u l=0.28u
XK9_SPPA_B_0 K9_SP_m1_B K9_AB_B VDD VDD pfet_03v3 w=15.0u l=0.28u
XK9_SPPB_B_0 K9_SP_m2_B D9_B K9_SP_m1_B VDD pfet_03v3 w=15.0u l=0.28u
XK9_SPPC_B_0 K9_SETP_B DPB_B K9_SP_m2_B VDD pfet_03v3 w=15.0u l=0.28u
XK9_SNNA_B_0 K9_SETN_B K9_AB_B VSS VSS nfet_03v3 w=2.5u l=0.28u
XK9_SNNB_B_0 K9_SETN_B D9_B VSS VSS nfet_03v3 w=2.5u l=0.28u
XK9_SNNC_B_0 K9_SETN_B DNB_B VSS VSS nfet_03v3 w=2.5u l=0.28u
XK9_SNPA_B_0 K9_SN_m1_B K9_AB_B VDD VDD pfet_03v3 w=15.0u l=0.28u
XK9_SNPB_B_0 K9_SN_m2_B D9_B K9_SN_m1_B VDD pfet_03v3 w=15.0u l=0.28u
XK9_SNPC_B_0 K9_SETN_B DNB_B K9_SN_m2_B VDD pfet_03v3 w=15.0u l=0.28u
XK9_PANA_B_0 K9_QP_B R_B VSS VSS nfet_03v3 w=2.5u l=0.28u
XK9_PANB_B_0 K9_QP_B K9_QPB_B VSS VSS nfet_03v3 w=2.5u l=0.28u
XK9_PAPA_B_0 K9_PA_m_B R_B VDD VDD pfet_03v3 w=10.0u l=0.28u
XK9_PAPB_B_0 K9_QP_B K9_QPB_B K9_PA_m_B VDD pfet_03v3 w=10.0u l=0.28u
XK9_PBNA_B_0 K9_QPB_B K9_SETP_B VSS VSS nfet_03v3 w=2.5u l=0.28u
XK9_PBNB_B_0 K9_QPB_B K9_QP_B VSS VSS nfet_03v3 w=2.5u l=0.28u
XK9_PBPA_B_0 K9_PB_m_B K9_SETP_B VDD VDD pfet_03v3 w=10.0u l=0.28u
XK9_PBPB_B_0 K9_QPB_B K9_QP_B K9_PB_m_B VDD pfet_03v3 w=10.0u l=0.28u
XK9_NANA_B_0 K9_QN_B R_B VSS VSS nfet_03v3 w=2.5u l=0.28u
XK9_NANB_B_0 K9_QN_B K9_QNB_B VSS VSS nfet_03v3 w=2.5u l=0.28u
XK9_NAPA_B_0 K9_NA_m_B R_B VDD VDD pfet_03v3 w=10.0u l=0.28u
XK9_NAPB_B_0 K9_QN_B K9_QNB_B K9_NA_m_B VDD pfet_03v3 w=10.0u l=0.28u
XK9_NBNA_B_0 K9_QNB_B K9_SETN_B VSS VSS nfet_03v3 w=2.5u l=0.28u
XK9_NBNB_B_0 K9_QNB_B K9_QN_B VSS VSS nfet_03v3 w=2.5u l=0.28u
XK9_NBPA_B_0 K9_NB_m_B K9_SETN_B VDD VDD pfet_03v3 w=10.0u l=0.28u
XK9_NBPB_B_0 K9_QNB_B K9_QN_B K9_NB_m_B VDD pfet_03v3 w=10.0u l=0.28u
XK9_DNA_B_0 D9_B K9_QPB_B K9_D_m_B VSS nfet_03v3 w=5.0u l=0.28u
XK9_DNB_B_0 K9_D_m_B K9_QNB_B VSS VSS nfet_03v3 w=5.0u l=0.28u
XK9_DPA_B_0 D9_B K9_QPB_B VDD VDD pfet_03v3 w=5.0u l=0.28u
XK9_DPB_B_0 D9_B K9_QNB_B VDD VDD pfet_03v3 w=5.0u l=0.28u
XXL_B D9_B DONEB EN_B OVERLOADB VDD VSS K0_QP_B K1_QP_B K2_QP_B K3_QP_B K4_QP_B K5_QP_B K6_QP_B K7_QP_B K8_QP_B K9_QP_B CODEB0 CODEB1 CODEB2 CODEB3 CODEB4 CODEB5 CODEB6 CODEB7 CODEB8 CODEB9 adc_code_reg
DANT0 VSS ACQ0 diode_nd2ps_03v3 area=1.124p pj=4.24u
DANT1 VSS ACQ1 diode_nd2ps_03v3 area=1.124p pj=4.24u
DANT2 VSS CLK diode_nd2ps_03v3 area=2.19p pj=5.92u
DANT3 VSS ILEN diode_nd2ps_03v3 area=2.89p pj=6.8u
DANT4 VSS K0_QP_A diode_nd2ps_03v3 area=0.36p pj=2.4u
DANT5 VSS K0_QP_B diode_nd2ps_03v3 area=0.36p pj=2.4u
DANT6 VSS K6_QP_A diode_nd2ps_03v3 area=0.36p pj=2.4u
DANT7 VSS K6_QP_B diode_nd2ps_03v3 area=0.36p pj=2.4u
DANT8 VSS VDD diode_nd2ps_03v3 area=0.4096p pj=2.56u
DANT9 VSS VDD diode_nd2ps_03v3 area=0.4624p pj=2.72u
DANT10 VSS EN diode_nd2ps_03v3 area=12.04p pj=13.88u
DANT11 VSS CODE0 diode_nd2ps_03v3 area=12.04p pj=13.88u
DANT12 VSS CODE1 diode_nd2ps_03v3 area=12.04p pj=13.88u
DANT13 VSS CODE2 diode_nd2ps_03v3 area=12.04p pj=13.88u
DANT14 VSS CODE3 diode_nd2ps_03v3 area=12.04p pj=13.88u
DANT15 VSS CODE4 diode_nd2ps_03v3 area=12.04p pj=13.88u
DANT16 VSS CODE5 diode_nd2ps_03v3 area=12.04p pj=13.88u
DANT17 VSS CODE6 diode_nd2ps_03v3 area=12.04p pj=13.88u
DANT18 VSS CODE7 diode_nd2ps_03v3 area=12.04p pj=13.88u
DANT19 VSS CODE8 diode_nd2ps_03v3 area=12.04p pj=13.88u
DANT20 VSS CODE9 diode_nd2ps_03v3 area=12.04p pj=13.88u
DANT21 VSS DONE diode_nd2ps_03v3 area=12.04p pj=13.88u
DANT22 VSS OVERLOAD diode_nd2ps_03v3 area=12.04p pj=13.88u
DANT23 VSS CODEB0 diode_nd2ps_03v3 area=12.04p pj=13.88u
DANT24 VSS CODEB1 diode_nd2ps_03v3 area=12.04p pj=13.88u
DANT25 VSS CODEB2 diode_nd2ps_03v3 area=12.04p pj=13.88u
DANT26 VSS CODEB3 diode_nd2ps_03v3 area=12.04p pj=13.88u
DANT27 VSS CODEB4 diode_nd2ps_03v3 area=12.04p pj=13.88u
DANT28 VSS CODEB5 diode_nd2ps_03v3 area=12.04p pj=13.88u
DANT29 VSS CODEB6 diode_nd2ps_03v3 area=12.04p pj=13.88u
DANT30 VSS CODEB7 diode_nd2ps_03v3 area=12.04p pj=13.88u
DANT31 VSS CODEB8 diode_nd2ps_03v3 area=12.04p pj=13.88u
DANT32 VSS CODEB9 diode_nd2ps_03v3 area=12.04p pj=13.88u
DANT33 VSS DONEB diode_nd2ps_03v3 area=12.04p pj=13.88u
DANT34 VSS OVERLOADB diode_nd2ps_03v3 area=12.04p pj=13.88u
.ends
