* pt_dac_q: transistor-level schematic of converter block dac_q (gf180mcuD).
* Generated by analog/converters/flow.py from circuits.py; do not edit.
* Standard cells: include /pdk/gf180mcuD/libs.ref/gf180mcu_fd_sc_mcu7t5v0/spice/gf180mcu_fd_sc_mcu7t5v0.spice
* AP4: bias/load and cap rows merged, divider resistors as 2 x 25 um, 0.3 um track/trunk spacing, trunk bank ordered so ATB_BIAS/HG/VCASC sit between static nets
.subckt dac_logic clk en hold_zero load_en_b out_en VDD VSS bn[0] bn[1] bn[2] bn[3] bnb[0] bnb[1] bnb[2] bnb[3] code_tc[0] code_tc[1] code_tc[2] code_tc[3] code_tc[4] code_tc[5] code_tc[6] code_tc[7] code_tc[8] code_tc[9] th[0] th[1] th[2] th[3] th[4] th[5] th[6] th[7] th[8] th[9] th[10] th[11] th[12] th[13] th[14] th[15] th[16] th[17] th[18] th[19] th[20] th[21] th[22] th[23] th[24] th[25] th[26] th[27] th[28] th[29] th[30] th[31] th[32] th[33] th[34] th[35] th[36] th[37] th[38] th[39] th[40] th[41] th[42] th[43] th[44] th[45] th[46] th[47] th[48] th[49] th[50] th[51] th[52] th[53] th[54] th[55] th[56] th[57] th[58] th[59] th[60] th[61] th[62] thb[0] thb[1] thb[2] thb[3] thb[4] thb[5] thb[6] thb[7] thb[8] thb[9] thb[10] thb[11] thb[12] thb[13] thb[14] thb[15] thb[16] thb[17] thb[18] thb[19] thb[20] thb[21] thb[22] thb[23] thb[24] thb[25] thb[26] thb[27] thb[28] thb[29] thb[30] thb[31] thb[32] thb[33] thb[34] thb[35] thb[36] thb[37] thb[38] thb[39] thb[40] thb[41] thb[42] thb[43] thb[44] thb[45] thb[46] thb[47] thb[48] thb[49] thb[50] thb[51] thb[52] thb[53] thb[54] thb[55] thb[56] thb[57] thb[58] thb[59] thb[60] thb[61] thb[62]
XANTENNA_1 code_tc[0] VDD VDD VSS VSS gf180mcu_fd_sc_mcu7t5v0__antenna
XANTENNA_2 code_tc[1] VDD VDD VSS VSS gf180mcu_fd_sc_mcu7t5v0__antenna
XFILLER_0_100 VDD VDD VSS VSS gf180mcu_fd_sc_mcu7t5v0__fill_2
XFILLER_0_1000 VDD VDD VSS VSS gf180mcu_fd_sc_mcu7t5v0__fillcap_16
XFILLER_0_1022 VDD VDD VSS VSS gf180mcu_fd_sc_mcu7t5v0__fillcap_4
XFILLER_0_1030 VDD VDD VSS VSS gf180mcu_fd_sc_mcu7t5v0__fillcap_8
XFILLER_0_1038 VDD VDD VSS VSS gf180mcu_fd_sc_mcu7t5v0__fill_2
XFILLER_0_104 VDD VDD VSS VSS gf180mcu_fd_sc_mcu7t5v0__fill_1
XFILLER_0_1040 VDD VDD VSS VSS gf180mcu_fd_sc_mcu7t5v0__fill_1
XFILLER_0_1045 VDD VDD VSS VSS gf180mcu_fd_sc_mcu7t5v0__fillcap_8
XFILLER_0_1053 VDD VDD VSS VSS gf180mcu_fd_sc_mcu7t5v0__fill_1
XFILLER_0_1056 VDD VDD VSS VSS gf180mcu_fd_sc_mcu7t5v0__fillcap_32
XFILLER_0_109 VDD VDD VSS VSS gf180mcu_fd_sc_mcu7t5v0__fillcap_8
XFILLER_0_1090 VDD VDD VSS VSS gf180mcu_fd_sc_mcu7t5v0__fillcap_16
XFILLER_0_1106 VDD VDD VSS VSS gf180mcu_fd_sc_mcu7t5v0__fillcap_8
XFILLER_0_1114 VDD VDD VSS VSS gf180mcu_fd_sc_mcu7t5v0__fill_2
XFILLER_0_117 VDD VDD VSS VSS gf180mcu_fd_sc_mcu7t5v0__fill_2
XFILLER_0_119 VDD VDD VSS VSS gf180mcu_fd_sc_mcu7t5v0__fill_1
XFILLER_0_124 VDD VDD VSS VSS gf180mcu_fd_sc_mcu7t5v0__fillcap_8
XFILLER_0_132 VDD VDD VSS VSS gf180mcu_fd_sc_mcu7t5v0__fillcap_4
XFILLER_0_138 VDD VDD VSS VSS gf180mcu_fd_sc_mcu7t5v0__fillcap_16
XFILLER_0_154 VDD VDD VSS VSS gf180mcu_fd_sc_mcu7t5v0__fill_2
XFILLER_0_156 VDD VDD VSS VSS gf180mcu_fd_sc_mcu7t5v0__fill_1
XFILLER_0_182 VDD VDD VSS VSS gf180mcu_fd_sc_mcu7t5v0__fill_2
XFILLER_0_184 VDD VDD VSS VSS gf180mcu_fd_sc_mcu7t5v0__fill_1
XFILLER_0_197 VDD VDD VSS VSS gf180mcu_fd_sc_mcu7t5v0__fill_2
XFILLER_0_2 VDD VDD VSS VSS gf180mcu_fd_sc_mcu7t5v0__fillcap_32
XFILLER_0_203 VDD VDD VSS VSS gf180mcu_fd_sc_mcu7t5v0__fill_1
XFILLER_0_206 VDD VDD VSS VSS gf180mcu_fd_sc_mcu7t5v0__fillcap_16
XFILLER_0_222 VDD VDD VSS VSS gf180mcu_fd_sc_mcu7t5v0__fillcap_8
XFILLER_0_230 VDD VDD VSS VSS gf180mcu_fd_sc_mcu7t5v0__fillcap_4
XFILLER_0_240 VDD VDD VSS VSS gf180mcu_fd_sc_mcu7t5v0__fillcap_8
XFILLER_0_248 VDD VDD VSS VSS gf180mcu_fd_sc_mcu7t5v0__fill_1
XFILLER_0_253 VDD VDD VSS VSS gf180mcu_fd_sc_mcu7t5v0__fillcap_16
XFILLER_0_269 VDD VDD VSS VSS gf180mcu_fd_sc_mcu7t5v0__fill_2
XFILLER_0_271 VDD VDD VSS VSS gf180mcu_fd_sc_mcu7t5v0__fill_1
XFILLER_0_274 VDD VDD VSS VSS gf180mcu_fd_sc_mcu7t5v0__fillcap_32
XFILLER_0_308 VDD VDD VSS VSS gf180mcu_fd_sc_mcu7t5v0__fillcap_16
XFILLER_0_328 VDD VDD VSS VSS gf180mcu_fd_sc_mcu7t5v0__fillcap_8
XFILLER_0_342 VDD VDD VSS VSS gf180mcu_fd_sc_mcu7t5v0__fillcap_32
XFILLER_0_36 VDD VDD VSS VSS gf180mcu_fd_sc_mcu7t5v0__fillcap_4
XFILLER_0_40 VDD VDD VSS VSS gf180mcu_fd_sc_mcu7t5v0__fill_2
XFILLER_0_406 VDD VDD VSS VSS gf180mcu_fd_sc_mcu7t5v0__fill_2
XFILLER_0_410 VDD VDD VSS VSS gf180mcu_fd_sc_mcu7t5v0__fillcap_32
XFILLER_0_444 VDD VDD VSS VSS gf180mcu_fd_sc_mcu7t5v0__fillcap_8
XFILLER_0_452 VDD VDD VSS VSS gf180mcu_fd_sc_mcu7t5v0__fill_1
XFILLER_0_457 VDD VDD VSS VSS gf180mcu_fd_sc_mcu7t5v0__fillcap_8
XFILLER_0_46 VDD VDD VSS VSS gf180mcu_fd_sc_mcu7t5v0__fillcap_8
XFILLER_0_465 VDD VDD VSS VSS gf180mcu_fd_sc_mcu7t5v0__fill_1
XFILLER_0_470 VDD VDD VSS VSS gf180mcu_fd_sc_mcu7t5v0__fillcap_4
XFILLER_0_474 VDD VDD VSS VSS gf180mcu_fd_sc_mcu7t5v0__fill_2
XFILLER_0_478 VDD VDD VSS VSS gf180mcu_fd_sc_mcu7t5v0__fillcap_4
XFILLER_0_482 VDD VDD VSS VSS gf180mcu_fd_sc_mcu7t5v0__fill_2
XFILLER_0_488 VDD VDD VSS VSS gf180mcu_fd_sc_mcu7t5v0__fillcap_16
XFILLER_0_504 VDD VDD VSS VSS gf180mcu_fd_sc_mcu7t5v0__fillcap_4
XFILLER_0_508 VDD VDD VSS VSS gf180mcu_fd_sc_mcu7t5v0__fill_2
XFILLER_0_512 VDD VDD VSS VSS gf180mcu_fd_sc_mcu7t5v0__fillcap_4
XFILLER_0_520 VDD VDD VSS VSS gf180mcu_fd_sc_mcu7t5v0__fillcap_16
XFILLER_0_54 VDD VDD VSS VSS gf180mcu_fd_sc_mcu7t5v0__fillcap_4
XFILLER_0_540 VDD VDD VSS VSS gf180mcu_fd_sc_mcu7t5v0__fillcap_4
XFILLER_0_546 VDD VDD VSS VSS gf180mcu_fd_sc_mcu7t5v0__fillcap_32
XFILLER_0_580 VDD VDD VSS VSS gf180mcu_fd_sc_mcu7t5v0__fill_2
XFILLER_0_586 VDD VDD VSS VSS gf180mcu_fd_sc_mcu7t5v0__fillcap_16
XFILLER_0_602 VDD VDD VSS VSS gf180mcu_fd_sc_mcu7t5v0__fillcap_8
XFILLER_0_610 VDD VDD VSS VSS gf180mcu_fd_sc_mcu7t5v0__fill_2
XFILLER_0_614 VDD VDD VSS VSS gf180mcu_fd_sc_mcu7t5v0__fillcap_32
XFILLER_0_62 VDD VDD VSS VSS gf180mcu_fd_sc_mcu7t5v0__fillcap_4
XFILLER_0_652 VDD VDD VSS VSS gf180mcu_fd_sc_mcu7t5v0__fillcap_4
XFILLER_0_66 VDD VDD VSS VSS gf180mcu_fd_sc_mcu7t5v0__fill_2
XFILLER_0_660 VDD VDD VSS VSS gf180mcu_fd_sc_mcu7t5v0__fillcap_8
XFILLER_0_668 VDD VDD VSS VSS gf180mcu_fd_sc_mcu7t5v0__fillcap_4
XFILLER_0_672 VDD VDD VSS VSS gf180mcu_fd_sc_mcu7t5v0__fill_2
XFILLER_0_674 VDD VDD VSS VSS gf180mcu_fd_sc_mcu7t5v0__fill_1
XFILLER_0_679 VDD VDD VSS VSS gf180mcu_fd_sc_mcu7t5v0__fill_1
XFILLER_0_682 VDD VDD VSS VSS gf180mcu_fd_sc_mcu7t5v0__fillcap_8
XFILLER_0_690 VDD VDD VSS VSS gf180mcu_fd_sc_mcu7t5v0__fillcap_4
XFILLER_0_698 VDD VDD VSS VSS gf180mcu_fd_sc_mcu7t5v0__fillcap_8
XFILLER_0_70 VDD VDD VSS VSS gf180mcu_fd_sc_mcu7t5v0__fill_2
XFILLER_0_706 VDD VDD VSS VSS gf180mcu_fd_sc_mcu7t5v0__fillcap_4
XFILLER_0_716 VDD VDD VSS VSS gf180mcu_fd_sc_mcu7t5v0__fillcap_8
XFILLER_0_724 VDD VDD VSS VSS gf180mcu_fd_sc_mcu7t5v0__fillcap_4
XFILLER_0_732 VDD VDD VSS VSS gf180mcu_fd_sc_mcu7t5v0__fillcap_8
XFILLER_0_740 VDD VDD VSS VSS gf180mcu_fd_sc_mcu7t5v0__fill_2
XFILLER_0_742 VDD VDD VSS VSS gf180mcu_fd_sc_mcu7t5v0__fill_1
XFILLER_0_747 VDD VDD VSS VSS gf180mcu_fd_sc_mcu7t5v0__fill_1
XFILLER_0_750 VDD VDD VSS VSS gf180mcu_fd_sc_mcu7t5v0__fill_2
XFILLER_0_76 VDD VDD VSS VSS gf180mcu_fd_sc_mcu7t5v0__fillcap_8
XFILLER_0_762 VDD VDD VSS VSS gf180mcu_fd_sc_mcu7t5v0__fillcap_16
XFILLER_0_778 VDD VDD VSS VSS gf180mcu_fd_sc_mcu7t5v0__fillcap_4
XFILLER_0_784 VDD VDD VSS VSS gf180mcu_fd_sc_mcu7t5v0__fillcap_4
XFILLER_0_792 VDD VDD VSS VSS gf180mcu_fd_sc_mcu7t5v0__fillcap_8
XFILLER_0_800 VDD VDD VSS VSS gf180mcu_fd_sc_mcu7t5v0__fillcap_4
XFILLER_0_808 VDD VDD VSS VSS gf180mcu_fd_sc_mcu7t5v0__fillcap_8
XFILLER_0_818 VDD VDD VSS VSS gf180mcu_fd_sc_mcu7t5v0__fillcap_16
XFILLER_0_834 VDD VDD VSS VSS gf180mcu_fd_sc_mcu7t5v0__fillcap_8
XFILLER_0_84 VDD VDD VSS VSS gf180mcu_fd_sc_mcu7t5v0__fillcap_4
XFILLER_0_846 VDD VDD VSS VSS gf180mcu_fd_sc_mcu7t5v0__fillcap_4
XFILLER_0_856 VDD VDD VSS VSS gf180mcu_fd_sc_mcu7t5v0__fillcap_8
XFILLER_0_864 VDD VDD VSS VSS gf180mcu_fd_sc_mcu7t5v0__fill_1
XFILLER_0_875 VDD VDD VSS VSS gf180mcu_fd_sc_mcu7t5v0__fillcap_8
XFILLER_0_883 VDD VDD VSS VSS gf180mcu_fd_sc_mcu7t5v0__fill_1
XFILLER_0_886 VDD VDD VSS VSS gf180mcu_fd_sc_mcu7t5v0__fillcap_16
XFILLER_0_902 VDD VDD VSS VSS gf180mcu_fd_sc_mcu7t5v0__fillcap_8
XFILLER_0_910 VDD VDD VSS VSS gf180mcu_fd_sc_mcu7t5v0__fillcap_4
XFILLER_0_92 VDD VDD VSS VSS gf180mcu_fd_sc_mcu7t5v0__fillcap_8
XFILLER_0_920 VDD VDD VSS VSS gf180mcu_fd_sc_mcu7t5v0__fillcap_8
XFILLER_0_928 VDD VDD VSS VSS gf180mcu_fd_sc_mcu7t5v0__fillcap_4
XFILLER_0_936 VDD VDD VSS VSS gf180mcu_fd_sc_mcu7t5v0__fillcap_8
XFILLER_0_944 VDD VDD VSS VSS gf180mcu_fd_sc_mcu7t5v0__fillcap_4
XFILLER_0_954 VDD VDD VSS VSS gf180mcu_fd_sc_mcu7t5v0__fillcap_32
XFILLER_0_988 VDD VDD VSS VSS gf180mcu_fd_sc_mcu7t5v0__fillcap_8
XFILLER_10_1022 VDD VDD VSS VSS gf180mcu_fd_sc_mcu7t5v0__fillcap_32
XFILLER_10_104 VDD VDD VSS VSS gf180mcu_fd_sc_mcu7t5v0__fillcap_32
XFILLER_10_1056 VDD VDD VSS VSS gf180mcu_fd_sc_mcu7t5v0__fillcap_32
XFILLER_10_1090 VDD VDD VSS VSS gf180mcu_fd_sc_mcu7t5v0__fillcap_16
XFILLER_10_1106 VDD VDD VSS VSS gf180mcu_fd_sc_mcu7t5v0__fillcap_8
XFILLER_10_1114 VDD VDD VSS VSS gf180mcu_fd_sc_mcu7t5v0__fill_2
XFILLER_10_138 VDD VDD VSS VSS gf180mcu_fd_sc_mcu7t5v0__fillcap_32
XFILLER_10_172 VDD VDD VSS VSS gf180mcu_fd_sc_mcu7t5v0__fillcap_32
XFILLER_10_2 VDD VDD VSS VSS gf180mcu_fd_sc_mcu7t5v0__fillcap_32
XFILLER_10_206 VDD VDD VSS VSS gf180mcu_fd_sc_mcu7t5v0__fillcap_32
XFILLER_10_240 VDD VDD VSS VSS gf180mcu_fd_sc_mcu7t5v0__fillcap_32
XFILLER_10_274 VDD VDD VSS VSS gf180mcu_fd_sc_mcu7t5v0__fillcap_32
XFILLER_10_308 VDD VDD VSS VSS gf180mcu_fd_sc_mcu7t5v0__fillcap_32
XFILLER_10_342 VDD VDD VSS VSS gf180mcu_fd_sc_mcu7t5v0__fillcap_32
XFILLER_10_36 VDD VDD VSS VSS gf180mcu_fd_sc_mcu7t5v0__fillcap_32
XFILLER_10_376 VDD VDD VSS VSS gf180mcu_fd_sc_mcu7t5v0__fillcap_32
XFILLER_10_410 VDD VDD VSS VSS gf180mcu_fd_sc_mcu7t5v0__fillcap_32
XFILLER_10_444 VDD VDD VSS VSS gf180mcu_fd_sc_mcu7t5v0__fillcap_32
XFILLER_10_478 VDD VDD VSS VSS gf180mcu_fd_sc_mcu7t5v0__fillcap_32
XFILLER_10_512 VDD VDD VSS VSS gf180mcu_fd_sc_mcu7t5v0__fillcap_32
XFILLER_10_546 VDD VDD VSS VSS gf180mcu_fd_sc_mcu7t5v0__fillcap_32
XFILLER_10_580 VDD VDD VSS VSS gf180mcu_fd_sc_mcu7t5v0__fillcap_32
XFILLER_10_614 VDD VDD VSS VSS gf180mcu_fd_sc_mcu7t5v0__fillcap_32
XFILLER_10_648 VDD VDD VSS VSS gf180mcu_fd_sc_mcu7t5v0__fillcap_32
XFILLER_10_682 VDD VDD VSS VSS gf180mcu_fd_sc_mcu7t5v0__fillcap_32
XFILLER_10_70 VDD VDD VSS VSS gf180mcu_fd_sc_mcu7t5v0__fillcap_32
XFILLER_10_716 VDD VDD VSS VSS gf180mcu_fd_sc_mcu7t5v0__fillcap_16
XFILLER_10_732 VDD VDD VSS VSS gf180mcu_fd_sc_mcu7t5v0__fillcap_8
XFILLER_10_750 VDD VDD VSS VSS gf180mcu_fd_sc_mcu7t5v0__fillcap_32
XFILLER_10_784 VDD VDD VSS VSS gf180mcu_fd_sc_mcu7t5v0__fillcap_16
XFILLER_10_800 VDD VDD VSS VSS gf180mcu_fd_sc_mcu7t5v0__fillcap_8
XFILLER_10_808 VDD VDD VSS VSS gf180mcu_fd_sc_mcu7t5v0__fill_1
XFILLER_10_814 VDD VDD VSS VSS gf180mcu_fd_sc_mcu7t5v0__fill_2
XFILLER_10_818 VDD VDD VSS VSS gf180mcu_fd_sc_mcu7t5v0__fillcap_4
XFILLER_10_830 VDD VDD VSS VSS gf180mcu_fd_sc_mcu7t5v0__fillcap_16
XFILLER_10_846 VDD VDD VSS VSS gf180mcu_fd_sc_mcu7t5v0__fillcap_4
XFILLER_10_852 VDD VDD VSS VSS gf180mcu_fd_sc_mcu7t5v0__fillcap_32
XFILLER_10_886 VDD VDD VSS VSS gf180mcu_fd_sc_mcu7t5v0__fillcap_32
XFILLER_10_920 VDD VDD VSS VSS gf180mcu_fd_sc_mcu7t5v0__fillcap_32
XFILLER_10_954 VDD VDD VSS VSS gf180mcu_fd_sc_mcu7t5v0__fillcap_32
XFILLER_10_988 VDD VDD VSS VSS gf180mcu_fd_sc_mcu7t5v0__fillcap_32
XFILLER_1_1052 VDD VDD VSS VSS gf180mcu_fd_sc_mcu7t5v0__fillcap_4
XFILLER_1_1056 VDD VDD VSS VSS gf180mcu_fd_sc_mcu7t5v0__fill_1
XFILLER_1_1061 VDD VDD VSS VSS gf180mcu_fd_sc_mcu7t5v0__fillcap_8
XFILLER_1_1069 VDD VDD VSS VSS gf180mcu_fd_sc_mcu7t5v0__fillcap_4
XFILLER_1_1073 VDD VDD VSS VSS gf180mcu_fd_sc_mcu7t5v0__fill_1
XFILLER_1_1078 VDD VDD VSS VSS gf180mcu_fd_sc_mcu7t5v0__fillcap_4
XFILLER_1_1082 VDD VDD VSS VSS gf180mcu_fd_sc_mcu7t5v0__fill_1
XFILLER_1_1093 VDD VDD VSS VSS gf180mcu_fd_sc_mcu7t5v0__fillcap_16
XFILLER_1_1109 VDD VDD VSS VSS gf180mcu_fd_sc_mcu7t5v0__fillcap_4
XFILLER_1_1113 VDD VDD VSS VSS gf180mcu_fd_sc_mcu7t5v0__fill_2
XFILLER_1_1115 VDD VDD VSS VSS gf180mcu_fd_sc_mcu7t5v0__fill_1
XFILLER_1_146 VDD VDD VSS VSS gf180mcu_fd_sc_mcu7t5v0__fillcap_4
XFILLER_1_150 VDD VDD VSS VSS gf180mcu_fd_sc_mcu7t5v0__fill_1
XFILLER_1_18 VDD VDD VSS VSS gf180mcu_fd_sc_mcu7t5v0__fillcap_4
XFILLER_1_2 VDD VDD VSS VSS gf180mcu_fd_sc_mcu7t5v0__fillcap_16
XFILLER_1_212 VDD VDD VSS VSS gf180mcu_fd_sc_mcu7t5v0__fillcap_4
XFILLER_1_216 VDD VDD VSS VSS gf180mcu_fd_sc_mcu7t5v0__fill_2
XFILLER_1_22 VDD VDD VSS VSS gf180mcu_fd_sc_mcu7t5v0__fill_2
XFILLER_1_222 VDD VDD VSS VSS gf180mcu_fd_sc_mcu7t5v0__fill_2
XFILLER_1_24 VDD VDD VSS VSS gf180mcu_fd_sc_mcu7t5v0__fill_1
XFILLER_1_266 VDD VDD VSS VSS gf180mcu_fd_sc_mcu7t5v0__fillcap_8
XFILLER_1_274 VDD VDD VSS VSS gf180mcu_fd_sc_mcu7t5v0__fill_2
XFILLER_1_282 VDD VDD VSS VSS gf180mcu_fd_sc_mcu7t5v0__fillcap_8
XFILLER_1_29 VDD VDD VSS VSS gf180mcu_fd_sc_mcu7t5v0__fillcap_4
XFILLER_1_290 VDD VDD VSS VSS gf180mcu_fd_sc_mcu7t5v0__fill_1
XFILLER_1_295 VDD VDD VSS VSS gf180mcu_fd_sc_mcu7t5v0__fillcap_8
XFILLER_1_303 VDD VDD VSS VSS gf180mcu_fd_sc_mcu7t5v0__fillcap_4
XFILLER_1_307 VDD VDD VSS VSS gf180mcu_fd_sc_mcu7t5v0__fill_2
XFILLER_1_33 VDD VDD VSS VSS gf180mcu_fd_sc_mcu7t5v0__fill_2
XFILLER_1_347 VDD VDD VSS VSS gf180mcu_fd_sc_mcu7t5v0__fill_2
XFILLER_1_349 VDD VDD VSS VSS gf180mcu_fd_sc_mcu7t5v0__fill_1
XFILLER_1_35 VDD VDD VSS VSS gf180mcu_fd_sc_mcu7t5v0__fill_1
XFILLER_1_352 VDD VDD VSS VSS gf180mcu_fd_sc_mcu7t5v0__fill_2
XFILLER_1_354 VDD VDD VSS VSS gf180mcu_fd_sc_mcu7t5v0__fill_1
XFILLER_1_359 VDD VDD VSS VSS gf180mcu_fd_sc_mcu7t5v0__fillcap_4
XFILLER_1_363 VDD VDD VSS VSS gf180mcu_fd_sc_mcu7t5v0__fill_2
XFILLER_1_365 VDD VDD VSS VSS gf180mcu_fd_sc_mcu7t5v0__fill_1
XFILLER_1_426 VDD VDD VSS VSS gf180mcu_fd_sc_mcu7t5v0__fillcap_4
XFILLER_1_430 VDD VDD VSS VSS gf180mcu_fd_sc_mcu7t5v0__fill_2
XFILLER_1_432 VDD VDD VSS VSS gf180mcu_fd_sc_mcu7t5v0__fill_1
XFILLER_1_437 VDD VDD VSS VSS gf180mcu_fd_sc_mcu7t5v0__fill_2
XFILLER_1_439 VDD VDD VSS VSS gf180mcu_fd_sc_mcu7t5v0__fill_1
XFILLER_1_492 VDD VDD VSS VSS gf180mcu_fd_sc_mcu7t5v0__fillcap_8
XFILLER_1_500 VDD VDD VSS VSS gf180mcu_fd_sc_mcu7t5v0__fill_2
XFILLER_1_502 VDD VDD VSS VSS gf180mcu_fd_sc_mcu7t5v0__fill_1
XFILLER_1_507 VDD VDD VSS VSS gf180mcu_fd_sc_mcu7t5v0__fillcap_4
XFILLER_1_511 VDD VDD VSS VSS gf180mcu_fd_sc_mcu7t5v0__fill_2
XFILLER_1_551 VDD VDD VSS VSS gf180mcu_fd_sc_mcu7t5v0__fillcap_8
XFILLER_1_559 VDD VDD VSS VSS gf180mcu_fd_sc_mcu7t5v0__fill_1
XFILLER_1_604 VDD VDD VSS VSS gf180mcu_fd_sc_mcu7t5v0__fillcap_8
XFILLER_1_612 VDD VDD VSS VSS gf180mcu_fd_sc_mcu7t5v0__fill_1
XFILLER_1_617 VDD VDD VSS VSS gf180mcu_fd_sc_mcu7t5v0__fillcap_8
XFILLER_1_625 VDD VDD VSS VSS gf180mcu_fd_sc_mcu7t5v0__fill_1
XFILLER_1_710 VDD VDD VSS VSS gf180mcu_fd_sc_mcu7t5v0__fillcap_8
XFILLER_1_718 VDD VDD VSS VSS gf180mcu_fd_sc_mcu7t5v0__fill_1
XFILLER_1_769 VDD VDD VSS VSS gf180mcu_fd_sc_mcu7t5v0__fill_1
XFILLER_1_772 VDD VDD VSS VSS gf180mcu_fd_sc_mcu7t5v0__fillcap_4
XFILLER_1_814 VDD VDD VSS VSS gf180mcu_fd_sc_mcu7t5v0__fillcap_4
XFILLER_1_818 VDD VDD VSS VSS gf180mcu_fd_sc_mcu7t5v0__fill_2
XFILLER_1_824 VDD VDD VSS VSS gf180mcu_fd_sc_mcu7t5v0__fill_2
XFILLER_1_832 VDD VDD VSS VSS gf180mcu_fd_sc_mcu7t5v0__fill_1
XFILLER_1_839 VDD VDD VSS VSS gf180mcu_fd_sc_mcu7t5v0__fill_1
XFILLER_1_882 VDD VDD VSS VSS gf180mcu_fd_sc_mcu7t5v0__fill_2
XFILLER_1_884 VDD VDD VSS VSS gf180mcu_fd_sc_mcu7t5v0__fill_1
XFILLER_1_889 VDD VDD VSS VSS gf180mcu_fd_sc_mcu7t5v0__fillcap_16
XFILLER_1_909 VDD VDD VSS VSS gf180mcu_fd_sc_mcu7t5v0__fill_1
XFILLER_1_912 VDD VDD VSS VSS gf180mcu_fd_sc_mcu7t5v0__fill_1
XFILLER_1_963 VDD VDD VSS VSS gf180mcu_fd_sc_mcu7t5v0__fill_1
XFILLER_1_968 VDD VDD VSS VSS gf180mcu_fd_sc_mcu7t5v0__fillcap_8
XFILLER_2_1017 VDD VDD VSS VSS gf180mcu_fd_sc_mcu7t5v0__fillcap_64
XFILLER_2_107 VDD VDD VSS VSS gf180mcu_fd_sc_mcu7t5v0__fillcap_32
XFILLER_2_1081 VDD VDD VSS VSS gf180mcu_fd_sc_mcu7t5v0__fillcap_4
XFILLER_2_1087 VDD VDD VSS VSS gf180mcu_fd_sc_mcu7t5v0__fillcap_16
XFILLER_2_1103 VDD VDD VSS VSS gf180mcu_fd_sc_mcu7t5v0__fillcap_8
XFILLER_2_1111 VDD VDD VSS VSS gf180mcu_fd_sc_mcu7t5v0__fillcap_4
XFILLER_2_1115 VDD VDD VSS VSS gf180mcu_fd_sc_mcu7t5v0__fill_1
XFILLER_2_139 VDD VDD VSS VSS gf180mcu_fd_sc_mcu7t5v0__fill_2
XFILLER_2_2 VDD VDD VSS VSS gf180mcu_fd_sc_mcu7t5v0__fillcap_32
XFILLER_2_227 VDD VDD VSS VSS gf180mcu_fd_sc_mcu7t5v0__fillcap_16
XFILLER_2_243 VDD VDD VSS VSS gf180mcu_fd_sc_mcu7t5v0__fill_2
XFILLER_2_273 VDD VDD VSS VSS gf180mcu_fd_sc_mcu7t5v0__fillcap_8
XFILLER_2_317 VDD VDD VSS VSS gf180mcu_fd_sc_mcu7t5v0__fillcap_16
XFILLER_2_333 VDD VDD VSS VSS gf180mcu_fd_sc_mcu7t5v0__fill_2
XFILLER_2_335 VDD VDD VSS VSS gf180mcu_fd_sc_mcu7t5v0__fill_1
XFILLER_2_34 VDD VDD VSS VSS gf180mcu_fd_sc_mcu7t5v0__fill_1
XFILLER_2_370 VDD VDD VSS VSS gf180mcu_fd_sc_mcu7t5v0__fillcap_4
XFILLER_2_374 VDD VDD VSS VSS gf180mcu_fd_sc_mcu7t5v0__fill_2
XFILLER_2_376 VDD VDD VSS VSS gf180mcu_fd_sc_mcu7t5v0__fill_1
XFILLER_2_457 VDD VDD VSS VSS gf180mcu_fd_sc_mcu7t5v0__fillcap_16
XFILLER_2_473 VDD VDD VSS VSS gf180mcu_fd_sc_mcu7t5v0__fillcap_4
XFILLER_2_477 VDD VDD VSS VSS gf180mcu_fd_sc_mcu7t5v0__fill_2
XFILLER_2_479 VDD VDD VSS VSS gf180mcu_fd_sc_mcu7t5v0__fill_1
XFILLER_2_514 VDD VDD VSS VSS gf180mcu_fd_sc_mcu7t5v0__fillcap_8
XFILLER_2_522 VDD VDD VSS VSS gf180mcu_fd_sc_mcu7t5v0__fill_2
XFILLER_2_524 VDD VDD VSS VSS gf180mcu_fd_sc_mcu7t5v0__fill_1
XFILLER_2_527 VDD VDD VSS VSS gf180mcu_fd_sc_mcu7t5v0__fillcap_16
XFILLER_2_543 VDD VDD VSS VSS gf180mcu_fd_sc_mcu7t5v0__fillcap_4
XFILLER_2_547 VDD VDD VSS VSS gf180mcu_fd_sc_mcu7t5v0__fill_2
XFILLER_2_549 VDD VDD VSS VSS gf180mcu_fd_sc_mcu7t5v0__fill_1
XFILLER_2_584 VDD VDD VSS VSS gf180mcu_fd_sc_mcu7t5v0__fillcap_8
XFILLER_2_592 VDD VDD VSS VSS gf180mcu_fd_sc_mcu7t5v0__fill_2
XFILLER_2_594 VDD VDD VSS VSS gf180mcu_fd_sc_mcu7t5v0__fill_1
XFILLER_2_675 VDD VDD VSS VSS gf180mcu_fd_sc_mcu7t5v0__fillcap_4
XFILLER_2_679 VDD VDD VSS VSS gf180mcu_fd_sc_mcu7t5v0__fill_2
XFILLER_2_681 VDD VDD VSS VSS gf180mcu_fd_sc_mcu7t5v0__fill_1
XFILLER_2_724 VDD VDD VSS VSS gf180mcu_fd_sc_mcu7t5v0__fillcap_4
XFILLER_2_728 VDD VDD VSS VSS gf180mcu_fd_sc_mcu7t5v0__fill_1
XFILLER_2_771 VDD VDD VSS VSS gf180mcu_fd_sc_mcu7t5v0__fillcap_16
XFILLER_2_787 VDD VDD VSS VSS gf180mcu_fd_sc_mcu7t5v0__fill_1
XFILLER_2_794 VDD VDD VSS VSS gf180mcu_fd_sc_mcu7t5v0__fillcap_4
XFILLER_2_798 VDD VDD VSS VSS gf180mcu_fd_sc_mcu7t5v0__fill_1
XFILLER_3_1018 VDD VDD VSS VSS gf180mcu_fd_sc_mcu7t5v0__fillcap_32
XFILLER_3_1052 VDD VDD VSS VSS gf180mcu_fd_sc_mcu7t5v0__fillcap_64
XFILLER_3_132 VDD VDD VSS VSS gf180mcu_fd_sc_mcu7t5v0__fillcap_8
XFILLER_3_2 VDD VDD VSS VSS gf180mcu_fd_sc_mcu7t5v0__fillcap_32
XFILLER_3_212 VDD VDD VSS VSS gf180mcu_fd_sc_mcu7t5v0__fillcap_4
XFILLER_3_216 VDD VDD VSS VSS gf180mcu_fd_sc_mcu7t5v0__fill_1
XFILLER_3_222 VDD VDD VSS VSS gf180mcu_fd_sc_mcu7t5v0__fillcap_4
XFILLER_3_226 VDD VDD VSS VSS gf180mcu_fd_sc_mcu7t5v0__fill_2
XFILLER_3_262 VDD VDD VSS VSS gf180mcu_fd_sc_mcu7t5v0__fillcap_16
XFILLER_3_278 VDD VDD VSS VSS gf180mcu_fd_sc_mcu7t5v0__fill_2
XFILLER_3_282 VDD VDD VSS VSS gf180mcu_fd_sc_mcu7t5v0__fillcap_8
XFILLER_3_290 VDD VDD VSS VSS gf180mcu_fd_sc_mcu7t5v0__fill_2
XFILLER_3_334 VDD VDD VSS VSS gf180mcu_fd_sc_mcu7t5v0__fill_1
XFILLER_3_34 VDD VDD VSS VSS gf180mcu_fd_sc_mcu7t5v0__fill_2
XFILLER_3_343 VDD VDD VSS VSS gf180mcu_fd_sc_mcu7t5v0__fillcap_4
XFILLER_3_347 VDD VDD VSS VSS gf180mcu_fd_sc_mcu7t5v0__fill_2
XFILLER_3_349 VDD VDD VSS VSS gf180mcu_fd_sc_mcu7t5v0__fill_1
XFILLER_3_352 VDD VDD VSS VSS gf180mcu_fd_sc_mcu7t5v0__fillcap_16
XFILLER_3_368 VDD VDD VSS VSS gf180mcu_fd_sc_mcu7t5v0__fillcap_4
XFILLER_3_372 VDD VDD VSS VSS gf180mcu_fd_sc_mcu7t5v0__fill_2
XFILLER_3_374 VDD VDD VSS VSS gf180mcu_fd_sc_mcu7t5v0__fill_1
XFILLER_3_401 VDD VDD VSS VSS gf180mcu_fd_sc_mcu7t5v0__fillcap_8
XFILLER_3_409 VDD VDD VSS VSS gf180mcu_fd_sc_mcu7t5v0__fill_2
XFILLER_3_411 VDD VDD VSS VSS gf180mcu_fd_sc_mcu7t5v0__fill_1
XFILLER_3_422 VDD VDD VSS VSS gf180mcu_fd_sc_mcu7t5v0__fillcap_16
XFILLER_3_438 VDD VDD VSS VSS gf180mcu_fd_sc_mcu7t5v0__fillcap_8
XFILLER_3_446 VDD VDD VSS VSS gf180mcu_fd_sc_mcu7t5v0__fill_2
XFILLER_3_488 VDD VDD VSS VSS gf180mcu_fd_sc_mcu7t5v0__fill_2
XFILLER_3_492 VDD VDD VSS VSS gf180mcu_fd_sc_mcu7t5v0__fillcap_8
XFILLER_3_500 VDD VDD VSS VSS gf180mcu_fd_sc_mcu7t5v0__fillcap_4
XFILLER_3_504 VDD VDD VSS VSS gf180mcu_fd_sc_mcu7t5v0__fill_2
XFILLER_3_540 VDD VDD VSS VSS gf180mcu_fd_sc_mcu7t5v0__fillcap_4
XFILLER_3_544 VDD VDD VSS VSS gf180mcu_fd_sc_mcu7t5v0__fill_2
XFILLER_3_556 VDD VDD VSS VSS gf180mcu_fd_sc_mcu7t5v0__fillcap_4
XFILLER_3_567 VDD VDD VSS VSS gf180mcu_fd_sc_mcu7t5v0__fill_1
XFILLER_3_576 VDD VDD VSS VSS gf180mcu_fd_sc_mcu7t5v0__fillcap_16
XFILLER_3_592 VDD VDD VSS VSS gf180mcu_fd_sc_mcu7t5v0__fillcap_4
XFILLER_3_604 VDD VDD VSS VSS gf180mcu_fd_sc_mcu7t5v0__fillcap_16
XFILLER_3_620 VDD VDD VSS VSS gf180mcu_fd_sc_mcu7t5v0__fillcap_4
XFILLER_3_624 VDD VDD VSS VSS gf180mcu_fd_sc_mcu7t5v0__fill_1
XFILLER_3_629 VDD VDD VSS VSS gf180mcu_fd_sc_mcu7t5v0__fill_1
XFILLER_3_632 VDD VDD VSS VSS gf180mcu_fd_sc_mcu7t5v0__fillcap_16
XFILLER_3_648 VDD VDD VSS VSS gf180mcu_fd_sc_mcu7t5v0__fill_2
XFILLER_3_702 VDD VDD VSS VSS gf180mcu_fd_sc_mcu7t5v0__fill_1
XFILLER_3_72 VDD VDD VSS VSS gf180mcu_fd_sc_mcu7t5v0__fillcap_16
XFILLER_3_745 VDD VDD VSS VSS gf180mcu_fd_sc_mcu7t5v0__fillcap_16
XFILLER_3_761 VDD VDD VSS VSS gf180mcu_fd_sc_mcu7t5v0__fillcap_8
XFILLER_3_769 VDD VDD VSS VSS gf180mcu_fd_sc_mcu7t5v0__fill_1
XFILLER_3_88 VDD VDD VSS VSS gf180mcu_fd_sc_mcu7t5v0__fillcap_8
XFILLER_3_96 VDD VDD VSS VSS gf180mcu_fd_sc_mcu7t5v0__fill_2
XFILLER_3_962 VDD VDD VSS VSS gf180mcu_fd_sc_mcu7t5v0__fillcap_16
XFILLER_3_978 VDD VDD VSS VSS gf180mcu_fd_sc_mcu7t5v0__fill_2
XFILLER_3_982 VDD VDD VSS VSS gf180mcu_fd_sc_mcu7t5v0__fill_2
XFILLER_4_100 VDD VDD VSS VSS gf180mcu_fd_sc_mcu7t5v0__fillcap_4
XFILLER_4_1006 VDD VDD VSS VSS gf180mcu_fd_sc_mcu7t5v0__fillcap_8
XFILLER_4_1014 VDD VDD VSS VSS gf180mcu_fd_sc_mcu7t5v0__fill_1
XFILLER_4_1017 VDD VDD VSS VSS gf180mcu_fd_sc_mcu7t5v0__fillcap_64
XFILLER_4_104 VDD VDD VSS VSS gf180mcu_fd_sc_mcu7t5v0__fill_1
XFILLER_4_107 VDD VDD VSS VSS gf180mcu_fd_sc_mcu7t5v0__fillcap_16
XFILLER_4_1081 VDD VDD VSS VSS gf180mcu_fd_sc_mcu7t5v0__fillcap_4
XFILLER_4_1087 VDD VDD VSS VSS gf180mcu_fd_sc_mcu7t5v0__fillcap_16
XFILLER_4_1103 VDD VDD VSS VSS gf180mcu_fd_sc_mcu7t5v0__fillcap_8
XFILLER_4_1111 VDD VDD VSS VSS gf180mcu_fd_sc_mcu7t5v0__fillcap_4
XFILLER_4_1115 VDD VDD VSS VSS gf180mcu_fd_sc_mcu7t5v0__fill_1
XFILLER_4_123 VDD VDD VSS VSS gf180mcu_fd_sc_mcu7t5v0__fill_1
XFILLER_4_158 VDD VDD VSS VSS gf180mcu_fd_sc_mcu7t5v0__fillcap_4
XFILLER_4_162 VDD VDD VSS VSS gf180mcu_fd_sc_mcu7t5v0__fill_2
XFILLER_4_164 VDD VDD VSS VSS gf180mcu_fd_sc_mcu7t5v0__fill_1
XFILLER_4_2 VDD VDD VSS VSS gf180mcu_fd_sc_mcu7t5v0__fillcap_32
XFILLER_4_227 VDD VDD VSS VSS gf180mcu_fd_sc_mcu7t5v0__fillcap_8
XFILLER_4_273 VDD VDD VSS VSS gf180mcu_fd_sc_mcu7t5v0__fillcap_16
XFILLER_4_289 VDD VDD VSS VSS gf180mcu_fd_sc_mcu7t5v0__fillcap_8
XFILLER_4_297 VDD VDD VSS VSS gf180mcu_fd_sc_mcu7t5v0__fill_2
XFILLER_4_317 VDD VDD VSS VSS gf180mcu_fd_sc_mcu7t5v0__fillcap_64
XFILLER_4_34 VDD VDD VSS VSS gf180mcu_fd_sc_mcu7t5v0__fill_1
XFILLER_4_37 VDD VDD VSS VSS gf180mcu_fd_sc_mcu7t5v0__fillcap_8
XFILLER_4_381 VDD VDD VSS VSS gf180mcu_fd_sc_mcu7t5v0__fillcap_4
XFILLER_4_391 VDD VDD VSS VSS gf180mcu_fd_sc_mcu7t5v0__fillcap_32
XFILLER_4_423 VDD VDD VSS VSS gf180mcu_fd_sc_mcu7t5v0__fillcap_16
XFILLER_4_439 VDD VDD VSS VSS gf180mcu_fd_sc_mcu7t5v0__fillcap_8
XFILLER_4_45 VDD VDD VSS VSS gf180mcu_fd_sc_mcu7t5v0__fillcap_4
XFILLER_4_457 VDD VDD VSS VSS gf180mcu_fd_sc_mcu7t5v0__fillcap_16
XFILLER_4_473 VDD VDD VSS VSS gf180mcu_fd_sc_mcu7t5v0__fillcap_4
XFILLER_4_49 VDD VDD VSS VSS gf180mcu_fd_sc_mcu7t5v0__fill_1
XFILLER_4_511 VDD VDD VSS VSS gf180mcu_fd_sc_mcu7t5v0__fillcap_8
XFILLER_4_519 VDD VDD VSS VSS gf180mcu_fd_sc_mcu7t5v0__fillcap_4
XFILLER_4_523 VDD VDD VSS VSS gf180mcu_fd_sc_mcu7t5v0__fill_2
XFILLER_4_527 VDD VDD VSS VSS gf180mcu_fd_sc_mcu7t5v0__fillcap_8
XFILLER_4_535 VDD VDD VSS VSS gf180mcu_fd_sc_mcu7t5v0__fillcap_4
XFILLER_4_539 VDD VDD VSS VSS gf180mcu_fd_sc_mcu7t5v0__fill_1
XFILLER_4_574 VDD VDD VSS VSS gf180mcu_fd_sc_mcu7t5v0__fillcap_16
XFILLER_4_590 VDD VDD VSS VSS gf180mcu_fd_sc_mcu7t5v0__fillcap_4
XFILLER_4_594 VDD VDD VSS VSS gf180mcu_fd_sc_mcu7t5v0__fill_1
XFILLER_4_597 VDD VDD VSS VSS gf180mcu_fd_sc_mcu7t5v0__fillcap_16
XFILLER_4_613 VDD VDD VSS VSS gf180mcu_fd_sc_mcu7t5v0__fillcap_4
XFILLER_4_651 VDD VDD VSS VSS gf180mcu_fd_sc_mcu7t5v0__fillcap_8
XFILLER_4_659 VDD VDD VSS VSS gf180mcu_fd_sc_mcu7t5v0__fillcap_4
XFILLER_4_663 VDD VDD VSS VSS gf180mcu_fd_sc_mcu7t5v0__fill_2
XFILLER_4_667 VDD VDD VSS VSS gf180mcu_fd_sc_mcu7t5v0__fillcap_16
XFILLER_4_683 VDD VDD VSS VSS gf180mcu_fd_sc_mcu7t5v0__fill_2
XFILLER_4_693 VDD VDD VSS VSS gf180mcu_fd_sc_mcu7t5v0__fillcap_8
XFILLER_4_737 VDD VDD VSS VSS gf180mcu_fd_sc_mcu7t5v0__fillcap_4
XFILLER_4_741 VDD VDD VSS VSS gf180mcu_fd_sc_mcu7t5v0__fill_2
XFILLER_4_743 VDD VDD VSS VSS gf180mcu_fd_sc_mcu7t5v0__fill_1
XFILLER_4_786 VDD VDD VSS VSS gf180mcu_fd_sc_mcu7t5v0__fillcap_16
XFILLER_4_802 VDD VDD VSS VSS gf180mcu_fd_sc_mcu7t5v0__fill_2
XFILLER_4_804 VDD VDD VSS VSS gf180mcu_fd_sc_mcu7t5v0__fill_1
XFILLER_4_807 VDD VDD VSS VSS gf180mcu_fd_sc_mcu7t5v0__fillcap_8
XFILLER_4_815 VDD VDD VSS VSS gf180mcu_fd_sc_mcu7t5v0__fillcap_4
XFILLER_4_819 VDD VDD VSS VSS gf180mcu_fd_sc_mcu7t5v0__fill_1
XFILLER_4_84 VDD VDD VSS VSS gf180mcu_fd_sc_mcu7t5v0__fillcap_16
XFILLER_4_860 VDD VDD VSS VSS gf180mcu_fd_sc_mcu7t5v0__fillcap_8
XFILLER_4_868 VDD VDD VSS VSS gf180mcu_fd_sc_mcu7t5v0__fill_1
XFILLER_4_881 VDD VDD VSS VSS gf180mcu_fd_sc_mcu7t5v0__fillcap_8
XFILLER_4_889 VDD VDD VSS VSS gf180mcu_fd_sc_mcu7t5v0__fillcap_4
XFILLER_4_893 VDD VDD VSS VSS gf180mcu_fd_sc_mcu7t5v0__fill_1
XFILLER_4_936 VDD VDD VSS VSS gf180mcu_fd_sc_mcu7t5v0__fillcap_8
XFILLER_4_944 VDD VDD VSS VSS gf180mcu_fd_sc_mcu7t5v0__fill_1
XFILLER_4_947 VDD VDD VSS VSS gf180mcu_fd_sc_mcu7t5v0__fillcap_8
XFILLER_4_955 VDD VDD VSS VSS gf180mcu_fd_sc_mcu7t5v0__fill_1
XFILLER_4_990 VDD VDD VSS VSS gf180mcu_fd_sc_mcu7t5v0__fillcap_16
XFILLER_5_1016 VDD VDD VSS VSS gf180mcu_fd_sc_mcu7t5v0__fillcap_32
XFILLER_5_1048 VDD VDD VSS VSS gf180mcu_fd_sc_mcu7t5v0__fill_2
XFILLER_5_1052 VDD VDD VSS VSS gf180mcu_fd_sc_mcu7t5v0__fillcap_64
XFILLER_5_136 VDD VDD VSS VSS gf180mcu_fd_sc_mcu7t5v0__fillcap_4
XFILLER_5_142 VDD VDD VSS VSS gf180mcu_fd_sc_mcu7t5v0__fillcap_32
XFILLER_5_174 VDD VDD VSS VSS gf180mcu_fd_sc_mcu7t5v0__fill_2
XFILLER_5_199 VDD VDD VSS VSS gf180mcu_fd_sc_mcu7t5v0__fillcap_8
XFILLER_5_2 VDD VDD VSS VSS gf180mcu_fd_sc_mcu7t5v0__fillcap_64
XFILLER_5_207 VDD VDD VSS VSS gf180mcu_fd_sc_mcu7t5v0__fill_2
XFILLER_5_209 VDD VDD VSS VSS gf180mcu_fd_sc_mcu7t5v0__fill_1
XFILLER_5_212 VDD VDD VSS VSS gf180mcu_fd_sc_mcu7t5v0__fillcap_16
XFILLER_5_228 VDD VDD VSS VSS gf180mcu_fd_sc_mcu7t5v0__fill_2
XFILLER_5_282 VDD VDD VSS VSS gf180mcu_fd_sc_mcu7t5v0__fillcap_64
XFILLER_5_346 VDD VDD VSS VSS gf180mcu_fd_sc_mcu7t5v0__fillcap_4
XFILLER_5_352 VDD VDD VSS VSS gf180mcu_fd_sc_mcu7t5v0__fillcap_16
XFILLER_5_368 VDD VDD VSS VSS gf180mcu_fd_sc_mcu7t5v0__fill_2
XFILLER_5_422 VDD VDD VSS VSS gf180mcu_fd_sc_mcu7t5v0__fillcap_16
XFILLER_5_438 VDD VDD VSS VSS gf180mcu_fd_sc_mcu7t5v0__fill_2
XFILLER_5_492 VDD VDD VSS VSS gf180mcu_fd_sc_mcu7t5v0__fill_2
XFILLER_5_498 VDD VDD VSS VSS gf180mcu_fd_sc_mcu7t5v0__fillcap_8
XFILLER_5_506 VDD VDD VSS VSS gf180mcu_fd_sc_mcu7t5v0__fillcap_4
XFILLER_5_562 VDD VDD VSS VSS gf180mcu_fd_sc_mcu7t5v0__fillcap_32
XFILLER_5_594 VDD VDD VSS VSS gf180mcu_fd_sc_mcu7t5v0__fillcap_16
XFILLER_5_610 VDD VDD VSS VSS gf180mcu_fd_sc_mcu7t5v0__fillcap_8
XFILLER_5_618 VDD VDD VSS VSS gf180mcu_fd_sc_mcu7t5v0__fillcap_4
XFILLER_5_640 VDD VDD VSS VSS gf180mcu_fd_sc_mcu7t5v0__fillcap_32
XFILLER_5_66 VDD VDD VSS VSS gf180mcu_fd_sc_mcu7t5v0__fillcap_4
XFILLER_5_672 VDD VDD VSS VSS gf180mcu_fd_sc_mcu7t5v0__fillcap_16
XFILLER_5_688 VDD VDD VSS VSS gf180mcu_fd_sc_mcu7t5v0__fillcap_4
XFILLER_5_692 VDD VDD VSS VSS gf180mcu_fd_sc_mcu7t5v0__fill_2
XFILLER_5_699 VDD VDD VSS VSS gf180mcu_fd_sc_mcu7t5v0__fill_1
XFILLER_5_702 VDD VDD VSS VSS gf180mcu_fd_sc_mcu7t5v0__fillcap_4
XFILLER_5_706 VDD VDD VSS VSS gf180mcu_fd_sc_mcu7t5v0__fill_2
XFILLER_5_708 VDD VDD VSS VSS gf180mcu_fd_sc_mcu7t5v0__fill_1
XFILLER_5_72 VDD VDD VSS VSS gf180mcu_fd_sc_mcu7t5v0__fillcap_64
XFILLER_5_735 VDD VDD VSS VSS gf180mcu_fd_sc_mcu7t5v0__fillcap_16
XFILLER_5_751 VDD VDD VSS VSS gf180mcu_fd_sc_mcu7t5v0__fill_2
XFILLER_5_757 VDD VDD VSS VSS gf180mcu_fd_sc_mcu7t5v0__fill_2
XFILLER_5_767 VDD VDD VSS VSS gf180mcu_fd_sc_mcu7t5v0__fill_2
XFILLER_5_769 VDD VDD VSS VSS gf180mcu_fd_sc_mcu7t5v0__fill_1
XFILLER_5_786 VDD VDD VSS VSS gf180mcu_fd_sc_mcu7t5v0__fillcap_8
XFILLER_5_794 VDD VDD VSS VSS gf180mcu_fd_sc_mcu7t5v0__fill_1
XFILLER_5_800 VDD VDD VSS VSS gf180mcu_fd_sc_mcu7t5v0__fillcap_16
XFILLER_5_816 VDD VDD VSS VSS gf180mcu_fd_sc_mcu7t5v0__fillcap_4
XFILLER_5_820 VDD VDD VSS VSS gf180mcu_fd_sc_mcu7t5v0__fill_1
XFILLER_5_832 VDD VDD VSS VSS gf180mcu_fd_sc_mcu7t5v0__fillcap_8
XFILLER_5_846 VDD VDD VSS VSS gf180mcu_fd_sc_mcu7t5v0__fill_1
XFILLER_5_878 VDD VDD VSS VSS gf180mcu_fd_sc_mcu7t5v0__fillcap_32
XFILLER_5_962 VDD VDD VSS VSS gf180mcu_fd_sc_mcu7t5v0__fillcap_16
XFILLER_5_978 VDD VDD VSS VSS gf180mcu_fd_sc_mcu7t5v0__fill_2
XFILLER_6_101 VDD VDD VSS VSS gf180mcu_fd_sc_mcu7t5v0__fillcap_4
XFILLER_6_1013 VDD VDD VSS VSS gf180mcu_fd_sc_mcu7t5v0__fill_2
XFILLER_6_1017 VDD VDD VSS VSS gf180mcu_fd_sc_mcu7t5v0__fillcap_64
XFILLER_6_107 VDD VDD VSS VSS gf180mcu_fd_sc_mcu7t5v0__fillcap_64
XFILLER_6_1081 VDD VDD VSS VSS gf180mcu_fd_sc_mcu7t5v0__fillcap_4
XFILLER_6_1087 VDD VDD VSS VSS gf180mcu_fd_sc_mcu7t5v0__fillcap_16
XFILLER_6_1103 VDD VDD VSS VSS gf180mcu_fd_sc_mcu7t5v0__fillcap_8
XFILLER_6_1111 VDD VDD VSS VSS gf180mcu_fd_sc_mcu7t5v0__fillcap_4
XFILLER_6_1115 VDD VDD VSS VSS gf180mcu_fd_sc_mcu7t5v0__fill_1
XFILLER_6_171 VDD VDD VSS VSS gf180mcu_fd_sc_mcu7t5v0__fillcap_4
XFILLER_6_177 VDD VDD VSS VSS gf180mcu_fd_sc_mcu7t5v0__fillcap_16
XFILLER_6_193 VDD VDD VSS VSS gf180mcu_fd_sc_mcu7t5v0__fillcap_8
XFILLER_6_2 VDD VDD VSS VSS gf180mcu_fd_sc_mcu7t5v0__fillcap_32
XFILLER_6_235 VDD VDD VSS VSS gf180mcu_fd_sc_mcu7t5v0__fillcap_8
XFILLER_6_243 VDD VDD VSS VSS gf180mcu_fd_sc_mcu7t5v0__fill_2
XFILLER_6_247 VDD VDD VSS VSS gf180mcu_fd_sc_mcu7t5v0__fillcap_4
XFILLER_6_251 VDD VDD VSS VSS gf180mcu_fd_sc_mcu7t5v0__fill_2
XFILLER_6_253 VDD VDD VSS VSS gf180mcu_fd_sc_mcu7t5v0__fill_1
XFILLER_6_288 VDD VDD VSS VSS gf180mcu_fd_sc_mcu7t5v0__fillcap_16
XFILLER_6_304 VDD VDD VSS VSS gf180mcu_fd_sc_mcu7t5v0__fillcap_8
XFILLER_6_312 VDD VDD VSS VSS gf180mcu_fd_sc_mcu7t5v0__fill_2
XFILLER_6_314 VDD VDD VSS VSS gf180mcu_fd_sc_mcu7t5v0__fill_1
XFILLER_6_317 VDD VDD VSS VSS gf180mcu_fd_sc_mcu7t5v0__fillcap_16
XFILLER_6_333 VDD VDD VSS VSS gf180mcu_fd_sc_mcu7t5v0__fillcap_8
XFILLER_6_34 VDD VDD VSS VSS gf180mcu_fd_sc_mcu7t5v0__fill_1
XFILLER_6_341 VDD VDD VSS VSS gf180mcu_fd_sc_mcu7t5v0__fillcap_4
XFILLER_6_345 VDD VDD VSS VSS gf180mcu_fd_sc_mcu7t5v0__fill_1
XFILLER_6_37 VDD VDD VSS VSS gf180mcu_fd_sc_mcu7t5v0__fillcap_64
XFILLER_6_380 VDD VDD VSS VSS gf180mcu_fd_sc_mcu7t5v0__fillcap_4
XFILLER_6_384 VDD VDD VSS VSS gf180mcu_fd_sc_mcu7t5v0__fill_1
XFILLER_6_387 VDD VDD VSS VSS gf180mcu_fd_sc_mcu7t5v0__fillcap_32
XFILLER_6_419 VDD VDD VSS VSS gf180mcu_fd_sc_mcu7t5v0__fill_1
XFILLER_6_431 VDD VDD VSS VSS gf180mcu_fd_sc_mcu7t5v0__fillcap_16
XFILLER_6_447 VDD VDD VSS VSS gf180mcu_fd_sc_mcu7t5v0__fillcap_8
XFILLER_6_457 VDD VDD VSS VSS gf180mcu_fd_sc_mcu7t5v0__fillcap_32
XFILLER_6_489 VDD VDD VSS VSS gf180mcu_fd_sc_mcu7t5v0__fillcap_4
XFILLER_6_493 VDD VDD VSS VSS gf180mcu_fd_sc_mcu7t5v0__fill_2
XFILLER_6_516 VDD VDD VSS VSS gf180mcu_fd_sc_mcu7t5v0__fillcap_8
XFILLER_6_524 VDD VDD VSS VSS gf180mcu_fd_sc_mcu7t5v0__fill_1
XFILLER_6_527 VDD VDD VSS VSS gf180mcu_fd_sc_mcu7t5v0__fillcap_8
XFILLER_6_535 VDD VDD VSS VSS gf180mcu_fd_sc_mcu7t5v0__fillcap_4
XFILLER_6_539 VDD VDD VSS VSS gf180mcu_fd_sc_mcu7t5v0__fill_2
XFILLER_6_541 VDD VDD VSS VSS gf180mcu_fd_sc_mcu7t5v0__fill_1
XFILLER_6_560 VDD VDD VSS VSS gf180mcu_fd_sc_mcu7t5v0__fillcap_16
XFILLER_6_576 VDD VDD VSS VSS gf180mcu_fd_sc_mcu7t5v0__fillcap_8
XFILLER_6_584 VDD VDD VSS VSS gf180mcu_fd_sc_mcu7t5v0__fill_1
XFILLER_6_593 VDD VDD VSS VSS gf180mcu_fd_sc_mcu7t5v0__fill_2
XFILLER_6_597 VDD VDD VSS VSS gf180mcu_fd_sc_mcu7t5v0__fill_2
XFILLER_6_599 VDD VDD VSS VSS gf180mcu_fd_sc_mcu7t5v0__fill_1
XFILLER_6_608 VDD VDD VSS VSS gf180mcu_fd_sc_mcu7t5v0__fillcap_32
XFILLER_6_640 VDD VDD VSS VSS gf180mcu_fd_sc_mcu7t5v0__fillcap_16
XFILLER_6_656 VDD VDD VSS VSS gf180mcu_fd_sc_mcu7t5v0__fillcap_8
XFILLER_6_664 VDD VDD VSS VSS gf180mcu_fd_sc_mcu7t5v0__fill_1
XFILLER_6_667 VDD VDD VSS VSS gf180mcu_fd_sc_mcu7t5v0__fillcap_16
XFILLER_6_688 VDD VDD VSS VSS gf180mcu_fd_sc_mcu7t5v0__fill_2
XFILLER_6_690 VDD VDD VSS VSS gf180mcu_fd_sc_mcu7t5v0__fill_1
XFILLER_6_704 VDD VDD VSS VSS gf180mcu_fd_sc_mcu7t5v0__fillcap_16
XFILLER_6_720 VDD VDD VSS VSS gf180mcu_fd_sc_mcu7t5v0__fillcap_8
XFILLER_6_728 VDD VDD VSS VSS gf180mcu_fd_sc_mcu7t5v0__fillcap_4
XFILLER_6_732 VDD VDD VSS VSS gf180mcu_fd_sc_mcu7t5v0__fill_2
XFILLER_6_734 VDD VDD VSS VSS gf180mcu_fd_sc_mcu7t5v0__fill_1
XFILLER_6_755 VDD VDD VSS VSS gf180mcu_fd_sc_mcu7t5v0__fill_2
XFILLER_6_757 VDD VDD VSS VSS gf180mcu_fd_sc_mcu7t5v0__fill_1
XFILLER_6_772 VDD VDD VSS VSS gf180mcu_fd_sc_mcu7t5v0__fillcap_32
XFILLER_6_804 VDD VDD VSS VSS gf180mcu_fd_sc_mcu7t5v0__fill_1
XFILLER_6_841 VDD VDD VSS VSS gf180mcu_fd_sc_mcu7t5v0__fillcap_8
XFILLER_6_877 VDD VDD VSS VSS gf180mcu_fd_sc_mcu7t5v0__fillcap_16
XFILLER_6_893 VDD VDD VSS VSS gf180mcu_fd_sc_mcu7t5v0__fillcap_8
XFILLER_6_901 VDD VDD VSS VSS gf180mcu_fd_sc_mcu7t5v0__fill_2
XFILLER_6_903 VDD VDD VSS VSS gf180mcu_fd_sc_mcu7t5v0__fill_1
XFILLER_6_938 VDD VDD VSS VSS gf180mcu_fd_sc_mcu7t5v0__fillcap_4
XFILLER_6_942 VDD VDD VSS VSS gf180mcu_fd_sc_mcu7t5v0__fill_2
XFILLER_6_944 VDD VDD VSS VSS gf180mcu_fd_sc_mcu7t5v0__fill_1
XFILLER_6_981 VDD VDD VSS VSS gf180mcu_fd_sc_mcu7t5v0__fillcap_32
XFILLER_7_1046 VDD VDD VSS VSS gf180mcu_fd_sc_mcu7t5v0__fillcap_4
XFILLER_7_1052 VDD VDD VSS VSS gf180mcu_fd_sc_mcu7t5v0__fillcap_64
XFILLER_7_136 VDD VDD VSS VSS gf180mcu_fd_sc_mcu7t5v0__fillcap_4
XFILLER_7_142 VDD VDD VSS VSS gf180mcu_fd_sc_mcu7t5v0__fillcap_64
XFILLER_7_2 VDD VDD VSS VSS gf180mcu_fd_sc_mcu7t5v0__fillcap_64
XFILLER_7_206 VDD VDD VSS VSS gf180mcu_fd_sc_mcu7t5v0__fillcap_4
XFILLER_7_282 VDD VDD VSS VSS gf180mcu_fd_sc_mcu7t5v0__fillcap_32
XFILLER_7_314 VDD VDD VSS VSS gf180mcu_fd_sc_mcu7t5v0__fillcap_8
XFILLER_7_322 VDD VDD VSS VSS gf180mcu_fd_sc_mcu7t5v0__fill_2
XFILLER_7_332 VDD VDD VSS VSS gf180mcu_fd_sc_mcu7t5v0__fillcap_8
XFILLER_7_340 VDD VDD VSS VSS gf180mcu_fd_sc_mcu7t5v0__fillcap_4
XFILLER_7_344 VDD VDD VSS VSS gf180mcu_fd_sc_mcu7t5v0__fill_1
XFILLER_7_349 VDD VDD VSS VSS gf180mcu_fd_sc_mcu7t5v0__fill_1
XFILLER_7_352 VDD VDD VSS VSS gf180mcu_fd_sc_mcu7t5v0__fillcap_16
XFILLER_7_368 VDD VDD VSS VSS gf180mcu_fd_sc_mcu7t5v0__fill_1
XFILLER_7_411 VDD VDD VSS VSS gf180mcu_fd_sc_mcu7t5v0__fillcap_8
XFILLER_7_419 VDD VDD VSS VSS gf180mcu_fd_sc_mcu7t5v0__fill_1
XFILLER_7_456 VDD VDD VSS VSS gf180mcu_fd_sc_mcu7t5v0__fillcap_32
XFILLER_7_488 VDD VDD VSS VSS gf180mcu_fd_sc_mcu7t5v0__fill_2
XFILLER_7_498 VDD VDD VSS VSS gf180mcu_fd_sc_mcu7t5v0__fill_2
XFILLER_7_500 VDD VDD VSS VSS gf180mcu_fd_sc_mcu7t5v0__fill_1
XFILLER_7_517 VDD VDD VSS VSS gf180mcu_fd_sc_mcu7t5v0__fillcap_32
XFILLER_7_549 VDD VDD VSS VSS gf180mcu_fd_sc_mcu7t5v0__fillcap_8
XFILLER_7_557 VDD VDD VSS VSS gf180mcu_fd_sc_mcu7t5v0__fill_2
XFILLER_7_559 VDD VDD VSS VSS gf180mcu_fd_sc_mcu7t5v0__fill_1
XFILLER_7_562 VDD VDD VSS VSS gf180mcu_fd_sc_mcu7t5v0__fillcap_16
XFILLER_7_612 VDD VDD VSS VSS gf180mcu_fd_sc_mcu7t5v0__fillcap_8
XFILLER_7_620 VDD VDD VSS VSS gf180mcu_fd_sc_mcu7t5v0__fill_2
XFILLER_7_632 VDD VDD VSS VSS gf180mcu_fd_sc_mcu7t5v0__fillcap_16
XFILLER_7_648 VDD VDD VSS VSS gf180mcu_fd_sc_mcu7t5v0__fillcap_8
XFILLER_7_656 VDD VDD VSS VSS gf180mcu_fd_sc_mcu7t5v0__fillcap_4
XFILLER_7_66 VDD VDD VSS VSS gf180mcu_fd_sc_mcu7t5v0__fillcap_4
XFILLER_7_660 VDD VDD VSS VSS gf180mcu_fd_sc_mcu7t5v0__fill_2
XFILLER_7_662 VDD VDD VSS VSS gf180mcu_fd_sc_mcu7t5v0__fill_1
XFILLER_7_674 VDD VDD VSS VSS gf180mcu_fd_sc_mcu7t5v0__fillcap_16
XFILLER_7_690 VDD VDD VSS VSS gf180mcu_fd_sc_mcu7t5v0__fillcap_4
XFILLER_7_702 VDD VDD VSS VSS gf180mcu_fd_sc_mcu7t5v0__fillcap_4
XFILLER_7_714 VDD VDD VSS VSS gf180mcu_fd_sc_mcu7t5v0__fillcap_8
XFILLER_7_72 VDD VDD VSS VSS gf180mcu_fd_sc_mcu7t5v0__fillcap_64
XFILLER_7_722 VDD VDD VSS VSS gf180mcu_fd_sc_mcu7t5v0__fillcap_4
XFILLER_7_726 VDD VDD VSS VSS gf180mcu_fd_sc_mcu7t5v0__fill_2
XFILLER_7_728 VDD VDD VSS VSS gf180mcu_fd_sc_mcu7t5v0__fill_1
XFILLER_7_765 VDD VDD VSS VSS gf180mcu_fd_sc_mcu7t5v0__fillcap_4
XFILLER_7_769 VDD VDD VSS VSS gf180mcu_fd_sc_mcu7t5v0__fill_1
XFILLER_7_772 VDD VDD VSS VSS gf180mcu_fd_sc_mcu7t5v0__fill_2
XFILLER_7_774 VDD VDD VSS VSS gf180mcu_fd_sc_mcu7t5v0__fill_1
XFILLER_7_809 VDD VDD VSS VSS gf180mcu_fd_sc_mcu7t5v0__fillcap_16
XFILLER_7_825 VDD VDD VSS VSS gf180mcu_fd_sc_mcu7t5v0__fillcap_8
XFILLER_7_833 VDD VDD VSS VSS gf180mcu_fd_sc_mcu7t5v0__fillcap_4
XFILLER_7_837 VDD VDD VSS VSS gf180mcu_fd_sc_mcu7t5v0__fill_2
XFILLER_7_839 VDD VDD VSS VSS gf180mcu_fd_sc_mcu7t5v0__fill_1
XFILLER_7_842 VDD VDD VSS VSS gf180mcu_fd_sc_mcu7t5v0__fillcap_16
XFILLER_7_858 VDD VDD VSS VSS gf180mcu_fd_sc_mcu7t5v0__fill_2
XFILLER_7_894 VDD VDD VSS VSS gf180mcu_fd_sc_mcu7t5v0__fillcap_16
XFILLER_7_962 VDD VDD VSS VSS gf180mcu_fd_sc_mcu7t5v0__fillcap_16
XFILLER_7_978 VDD VDD VSS VSS gf180mcu_fd_sc_mcu7t5v0__fill_2
XFILLER_7_982 VDD VDD VSS VSS gf180mcu_fd_sc_mcu7t5v0__fillcap_64
XFILLER_8_101 VDD VDD VSS VSS gf180mcu_fd_sc_mcu7t5v0__fillcap_4
XFILLER_8_1013 VDD VDD VSS VSS gf180mcu_fd_sc_mcu7t5v0__fill_2
XFILLER_8_1017 VDD VDD VSS VSS gf180mcu_fd_sc_mcu7t5v0__fillcap_64
XFILLER_8_107 VDD VDD VSS VSS gf180mcu_fd_sc_mcu7t5v0__fillcap_64
XFILLER_8_1081 VDD VDD VSS VSS gf180mcu_fd_sc_mcu7t5v0__fillcap_4
XFILLER_8_1087 VDD VDD VSS VSS gf180mcu_fd_sc_mcu7t5v0__fillcap_16
XFILLER_8_1103 VDD VDD VSS VSS gf180mcu_fd_sc_mcu7t5v0__fillcap_8
XFILLER_8_1111 VDD VDD VSS VSS gf180mcu_fd_sc_mcu7t5v0__fillcap_4
XFILLER_8_1115 VDD VDD VSS VSS gf180mcu_fd_sc_mcu7t5v0__fill_1
XFILLER_8_171 VDD VDD VSS VSS gf180mcu_fd_sc_mcu7t5v0__fillcap_4
XFILLER_8_177 VDD VDD VSS VSS gf180mcu_fd_sc_mcu7t5v0__fillcap_64
XFILLER_8_2 VDD VDD VSS VSS gf180mcu_fd_sc_mcu7t5v0__fillcap_32
XFILLER_8_241 VDD VDD VSS VSS gf180mcu_fd_sc_mcu7t5v0__fillcap_4
XFILLER_8_247 VDD VDD VSS VSS gf180mcu_fd_sc_mcu7t5v0__fillcap_16
XFILLER_8_271 VDD VDD VSS VSS gf180mcu_fd_sc_mcu7t5v0__fillcap_4
XFILLER_8_275 VDD VDD VSS VSS gf180mcu_fd_sc_mcu7t5v0__fill_1
XFILLER_8_310 VDD VDD VSS VSS gf180mcu_fd_sc_mcu7t5v0__fillcap_4
XFILLER_8_314 VDD VDD VSS VSS gf180mcu_fd_sc_mcu7t5v0__fill_1
XFILLER_8_317 VDD VDD VSS VSS gf180mcu_fd_sc_mcu7t5v0__fill_2
XFILLER_8_34 VDD VDD VSS VSS gf180mcu_fd_sc_mcu7t5v0__fill_1
XFILLER_8_353 VDD VDD VSS VSS gf180mcu_fd_sc_mcu7t5v0__fillcap_16
XFILLER_8_369 VDD VDD VSS VSS gf180mcu_fd_sc_mcu7t5v0__fillcap_4
XFILLER_8_37 VDD VDD VSS VSS gf180mcu_fd_sc_mcu7t5v0__fillcap_64
XFILLER_8_373 VDD VDD VSS VSS gf180mcu_fd_sc_mcu7t5v0__fill_2
XFILLER_8_381 VDD VDD VSS VSS gf180mcu_fd_sc_mcu7t5v0__fillcap_4
XFILLER_8_387 VDD VDD VSS VSS gf180mcu_fd_sc_mcu7t5v0__fillcap_32
XFILLER_8_419 VDD VDD VSS VSS gf180mcu_fd_sc_mcu7t5v0__fillcap_16
XFILLER_8_435 VDD VDD VSS VSS gf180mcu_fd_sc_mcu7t5v0__fillcap_4
XFILLER_8_439 VDD VDD VSS VSS gf180mcu_fd_sc_mcu7t5v0__fill_2
XFILLER_8_441 VDD VDD VSS VSS gf180mcu_fd_sc_mcu7t5v0__fill_1
XFILLER_8_446 VDD VDD VSS VSS gf180mcu_fd_sc_mcu7t5v0__fillcap_8
XFILLER_8_454 VDD VDD VSS VSS gf180mcu_fd_sc_mcu7t5v0__fill_1
XFILLER_8_457 VDD VDD VSS VSS gf180mcu_fd_sc_mcu7t5v0__fillcap_4
XFILLER_8_461 VDD VDD VSS VSS gf180mcu_fd_sc_mcu7t5v0__fill_2
XFILLER_8_463 VDD VDD VSS VSS gf180mcu_fd_sc_mcu7t5v0__fill_1
XFILLER_8_478 VDD VDD VSS VSS gf180mcu_fd_sc_mcu7t5v0__fillcap_32
XFILLER_8_516 VDD VDD VSS VSS gf180mcu_fd_sc_mcu7t5v0__fill_1
XFILLER_8_527 VDD VDD VSS VSS gf180mcu_fd_sc_mcu7t5v0__fillcap_32
XFILLER_8_559 VDD VDD VSS VSS gf180mcu_fd_sc_mcu7t5v0__fillcap_16
XFILLER_8_575 VDD VDD VSS VSS gf180mcu_fd_sc_mcu7t5v0__fill_2
XFILLER_8_577 VDD VDD VSS VSS gf180mcu_fd_sc_mcu7t5v0__fill_1
XFILLER_8_586 VDD VDD VSS VSS gf180mcu_fd_sc_mcu7t5v0__fillcap_8
XFILLER_8_594 VDD VDD VSS VSS gf180mcu_fd_sc_mcu7t5v0__fill_1
XFILLER_8_597 VDD VDD VSS VSS gf180mcu_fd_sc_mcu7t5v0__fillcap_32
XFILLER_8_629 VDD VDD VSS VSS gf180mcu_fd_sc_mcu7t5v0__fillcap_4
XFILLER_8_633 VDD VDD VSS VSS gf180mcu_fd_sc_mcu7t5v0__fill_1
XFILLER_8_650 VDD VDD VSS VSS gf180mcu_fd_sc_mcu7t5v0__fillcap_8
XFILLER_8_658 VDD VDD VSS VSS gf180mcu_fd_sc_mcu7t5v0__fill_1
XFILLER_8_683 VDD VDD VSS VSS gf180mcu_fd_sc_mcu7t5v0__fillcap_4
XFILLER_8_687 VDD VDD VSS VSS gf180mcu_fd_sc_mcu7t5v0__fill_2
XFILLER_8_689 VDD VDD VSS VSS gf180mcu_fd_sc_mcu7t5v0__fill_1
XFILLER_8_698 VDD VDD VSS VSS gf180mcu_fd_sc_mcu7t5v0__fillcap_16
XFILLER_8_714 VDD VDD VSS VSS gf180mcu_fd_sc_mcu7t5v0__fillcap_8
XFILLER_8_722 VDD VDD VSS VSS gf180mcu_fd_sc_mcu7t5v0__fillcap_4
XFILLER_8_726 VDD VDD VSS VSS gf180mcu_fd_sc_mcu7t5v0__fill_1
XFILLER_8_737 VDD VDD VSS VSS gf180mcu_fd_sc_mcu7t5v0__fillcap_4
XFILLER_8_741 VDD VDD VSS VSS gf180mcu_fd_sc_mcu7t5v0__fill_2
XFILLER_8_743 VDD VDD VSS VSS gf180mcu_fd_sc_mcu7t5v0__fill_1
XFILLER_8_802 VDD VDD VSS VSS gf180mcu_fd_sc_mcu7t5v0__fill_2
XFILLER_8_804 VDD VDD VSS VSS gf180mcu_fd_sc_mcu7t5v0__fill_1
XFILLER_8_843 VDD VDD VSS VSS gf180mcu_fd_sc_mcu7t5v0__fillcap_32
XFILLER_8_877 VDD VDD VSS VSS gf180mcu_fd_sc_mcu7t5v0__fillcap_32
XFILLER_8_909 VDD VDD VSS VSS gf180mcu_fd_sc_mcu7t5v0__fill_1
XFILLER_8_918 VDD VDD VSS VSS gf180mcu_fd_sc_mcu7t5v0__fillcap_16
XFILLER_8_934 VDD VDD VSS VSS gf180mcu_fd_sc_mcu7t5v0__fillcap_8
XFILLER_8_942 VDD VDD VSS VSS gf180mcu_fd_sc_mcu7t5v0__fill_2
XFILLER_8_944 VDD VDD VSS VSS gf180mcu_fd_sc_mcu7t5v0__fill_1
XFILLER_8_981 VDD VDD VSS VSS gf180mcu_fd_sc_mcu7t5v0__fillcap_32
XFILLER_9_1046 VDD VDD VSS VSS gf180mcu_fd_sc_mcu7t5v0__fillcap_4
XFILLER_9_1052 VDD VDD VSS VSS gf180mcu_fd_sc_mcu7t5v0__fillcap_64
XFILLER_9_136 VDD VDD VSS VSS gf180mcu_fd_sc_mcu7t5v0__fillcap_4
XFILLER_9_142 VDD VDD VSS VSS gf180mcu_fd_sc_mcu7t5v0__fillcap_64
XFILLER_9_2 VDD VDD VSS VSS gf180mcu_fd_sc_mcu7t5v0__fillcap_64
XFILLER_9_206 VDD VDD VSS VSS gf180mcu_fd_sc_mcu7t5v0__fillcap_4
XFILLER_9_212 VDD VDD VSS VSS gf180mcu_fd_sc_mcu7t5v0__fillcap_64
XFILLER_9_276 VDD VDD VSS VSS gf180mcu_fd_sc_mcu7t5v0__fillcap_4
XFILLER_9_282 VDD VDD VSS VSS gf180mcu_fd_sc_mcu7t5v0__fillcap_32
XFILLER_9_314 VDD VDD VSS VSS gf180mcu_fd_sc_mcu7t5v0__fillcap_4
XFILLER_9_318 VDD VDD VSS VSS gf180mcu_fd_sc_mcu7t5v0__fill_2
XFILLER_9_328 VDD VDD VSS VSS gf180mcu_fd_sc_mcu7t5v0__fillcap_16
XFILLER_9_344 VDD VDD VSS VSS gf180mcu_fd_sc_mcu7t5v0__fillcap_4
XFILLER_9_348 VDD VDD VSS VSS gf180mcu_fd_sc_mcu7t5v0__fill_2
XFILLER_9_352 VDD VDD VSS VSS gf180mcu_fd_sc_mcu7t5v0__fillcap_64
XFILLER_9_416 VDD VDD VSS VSS gf180mcu_fd_sc_mcu7t5v0__fillcap_4
XFILLER_9_422 VDD VDD VSS VSS gf180mcu_fd_sc_mcu7t5v0__fillcap_64
XFILLER_9_486 VDD VDD VSS VSS gf180mcu_fd_sc_mcu7t5v0__fillcap_4
XFILLER_9_492 VDD VDD VSS VSS gf180mcu_fd_sc_mcu7t5v0__fillcap_64
XFILLER_9_556 VDD VDD VSS VSS gf180mcu_fd_sc_mcu7t5v0__fillcap_4
XFILLER_9_562 VDD VDD VSS VSS gf180mcu_fd_sc_mcu7t5v0__fillcap_32
XFILLER_9_594 VDD VDD VSS VSS gf180mcu_fd_sc_mcu7t5v0__fillcap_16
XFILLER_9_610 VDD VDD VSS VSS gf180mcu_fd_sc_mcu7t5v0__fillcap_8
XFILLER_9_618 VDD VDD VSS VSS gf180mcu_fd_sc_mcu7t5v0__fillcap_4
XFILLER_9_626 VDD VDD VSS VSS gf180mcu_fd_sc_mcu7t5v0__fillcap_4
XFILLER_9_632 VDD VDD VSS VSS gf180mcu_fd_sc_mcu7t5v0__fillcap_4
XFILLER_9_636 VDD VDD VSS VSS gf180mcu_fd_sc_mcu7t5v0__fill_1
XFILLER_9_66 VDD VDD VSS VSS gf180mcu_fd_sc_mcu7t5v0__fillcap_4
XFILLER_9_671 VDD VDD VSS VSS gf180mcu_fd_sc_mcu7t5v0__fillcap_16
XFILLER_9_687 VDD VDD VSS VSS gf180mcu_fd_sc_mcu7t5v0__fillcap_8
XFILLER_9_695 VDD VDD VSS VSS gf180mcu_fd_sc_mcu7t5v0__fillcap_4
XFILLER_9_699 VDD VDD VSS VSS gf180mcu_fd_sc_mcu7t5v0__fill_1
XFILLER_9_702 VDD VDD VSS VSS gf180mcu_fd_sc_mcu7t5v0__fillcap_16
XFILLER_9_718 VDD VDD VSS VSS gf180mcu_fd_sc_mcu7t5v0__fillcap_8
XFILLER_9_72 VDD VDD VSS VSS gf180mcu_fd_sc_mcu7t5v0__fillcap_64
XFILLER_9_726 VDD VDD VSS VSS gf180mcu_fd_sc_mcu7t5v0__fillcap_4
XFILLER_9_730 VDD VDD VSS VSS gf180mcu_fd_sc_mcu7t5v0__fill_1
XFILLER_9_765 VDD VDD VSS VSS gf180mcu_fd_sc_mcu7t5v0__fillcap_4
XFILLER_9_769 VDD VDD VSS VSS gf180mcu_fd_sc_mcu7t5v0__fill_1
XFILLER_9_838 VDD VDD VSS VSS gf180mcu_fd_sc_mcu7t5v0__fill_2
XFILLER_9_842 VDD VDD VSS VSS gf180mcu_fd_sc_mcu7t5v0__fillcap_64
XFILLER_9_906 VDD VDD VSS VSS gf180mcu_fd_sc_mcu7t5v0__fillcap_4
XFILLER_9_912 VDD VDD VSS VSS gf180mcu_fd_sc_mcu7t5v0__fillcap_16
XFILLER_9_928 VDD VDD VSS VSS gf180mcu_fd_sc_mcu7t5v0__fillcap_4
XFILLER_9_932 VDD VDD VSS VSS gf180mcu_fd_sc_mcu7t5v0__fill_1
XFILLER_9_967 VDD VDD VSS VSS gf180mcu_fd_sc_mcu7t5v0__fillcap_8
XFILLER_9_975 VDD VDD VSS VSS gf180mcu_fd_sc_mcu7t5v0__fillcap_4
XFILLER_9_979 VDD VDD VSS VSS gf180mcu_fd_sc_mcu7t5v0__fill_1
XFILLER_9_982 VDD VDD VSS VSS gf180mcu_fd_sc_mcu7t5v0__fillcap_64
XPHY_EDGE_ROW_0_Left_11 VDD VDD VSS VSS gf180mcu_fd_sc_mcu7t5v0__endcap
XPHY_EDGE_ROW_0_Right_0 VDD VDD VSS VSS gf180mcu_fd_sc_mcu7t5v0__endcap
XPHY_EDGE_ROW_10_Left_21 VDD VDD VSS VSS gf180mcu_fd_sc_mcu7t5v0__endcap
XPHY_EDGE_ROW_10_Right_10 VDD VDD VSS VSS gf180mcu_fd_sc_mcu7t5v0__endcap
XPHY_EDGE_ROW_1_Left_12 VDD VDD VSS VSS gf180mcu_fd_sc_mcu7t5v0__endcap
XPHY_EDGE_ROW_1_Right_1 VDD VDD VSS VSS gf180mcu_fd_sc_mcu7t5v0__endcap
XPHY_EDGE_ROW_2_Left_13 VDD VDD VSS VSS gf180mcu_fd_sc_mcu7t5v0__endcap
XPHY_EDGE_ROW_2_Right_2 VDD VDD VSS VSS gf180mcu_fd_sc_mcu7t5v0__endcap
XPHY_EDGE_ROW_3_Left_14 VDD VDD VSS VSS gf180mcu_fd_sc_mcu7t5v0__endcap
XPHY_EDGE_ROW_3_Right_3 VDD VDD VSS VSS gf180mcu_fd_sc_mcu7t5v0__endcap
XPHY_EDGE_ROW_4_Left_15 VDD VDD VSS VSS gf180mcu_fd_sc_mcu7t5v0__endcap
XPHY_EDGE_ROW_4_Right_4 VDD VDD VSS VSS gf180mcu_fd_sc_mcu7t5v0__endcap
XPHY_EDGE_ROW_5_Left_16 VDD VDD VSS VSS gf180mcu_fd_sc_mcu7t5v0__endcap
XPHY_EDGE_ROW_5_Right_5 VDD VDD VSS VSS gf180mcu_fd_sc_mcu7t5v0__endcap
XPHY_EDGE_ROW_6_Left_17 VDD VDD VSS VSS gf180mcu_fd_sc_mcu7t5v0__endcap
XPHY_EDGE_ROW_6_Right_6 VDD VDD VSS VSS gf180mcu_fd_sc_mcu7t5v0__endcap
XPHY_EDGE_ROW_7_Left_18 VDD VDD VSS VSS gf180mcu_fd_sc_mcu7t5v0__endcap
XPHY_EDGE_ROW_7_Right_7 VDD VDD VSS VSS gf180mcu_fd_sc_mcu7t5v0__endcap
XPHY_EDGE_ROW_8_Left_19 VDD VDD VSS VSS gf180mcu_fd_sc_mcu7t5v0__endcap
XPHY_EDGE_ROW_8_Right_8 VDD VDD VSS VSS gf180mcu_fd_sc_mcu7t5v0__endcap
XPHY_EDGE_ROW_9_Left_20 VDD VDD VSS VSS gf180mcu_fd_sc_mcu7t5v0__endcap
XPHY_EDGE_ROW_9_Right_9 VDD VDD VSS VSS gf180mcu_fd_sc_mcu7t5v0__endcap
XTAP_TAPCELL_ROW_0_22 VDD VSS gf180mcu_fd_sc_mcu7t5v0__filltie
XTAP_TAPCELL_ROW_0_23 VDD VSS gf180mcu_fd_sc_mcu7t5v0__filltie
XTAP_TAPCELL_ROW_0_24 VDD VSS gf180mcu_fd_sc_mcu7t5v0__filltie
XTAP_TAPCELL_ROW_0_25 VDD VSS gf180mcu_fd_sc_mcu7t5v0__filltie
XTAP_TAPCELL_ROW_0_26 VDD VSS gf180mcu_fd_sc_mcu7t5v0__filltie
XTAP_TAPCELL_ROW_0_27 VDD VSS gf180mcu_fd_sc_mcu7t5v0__filltie
XTAP_TAPCELL_ROW_0_28 VDD VSS gf180mcu_fd_sc_mcu7t5v0__filltie
XTAP_TAPCELL_ROW_0_29 VDD VSS gf180mcu_fd_sc_mcu7t5v0__filltie
XTAP_TAPCELL_ROW_0_30 VDD VSS gf180mcu_fd_sc_mcu7t5v0__filltie
XTAP_TAPCELL_ROW_0_31 VDD VSS gf180mcu_fd_sc_mcu7t5v0__filltie
XTAP_TAPCELL_ROW_0_32 VDD VSS gf180mcu_fd_sc_mcu7t5v0__filltie
XTAP_TAPCELL_ROW_0_33 VDD VSS gf180mcu_fd_sc_mcu7t5v0__filltie
XTAP_TAPCELL_ROW_0_34 VDD VSS gf180mcu_fd_sc_mcu7t5v0__filltie
XTAP_TAPCELL_ROW_0_35 VDD VSS gf180mcu_fd_sc_mcu7t5v0__filltie
XTAP_TAPCELL_ROW_0_36 VDD VSS gf180mcu_fd_sc_mcu7t5v0__filltie
XTAP_TAPCELL_ROW_0_37 VDD VSS gf180mcu_fd_sc_mcu7t5v0__filltie
XTAP_TAPCELL_ROW_0_38 VDD VSS gf180mcu_fd_sc_mcu7t5v0__filltie
XTAP_TAPCELL_ROW_0_39 VDD VSS gf180mcu_fd_sc_mcu7t5v0__filltie
XTAP_TAPCELL_ROW_0_40 VDD VSS gf180mcu_fd_sc_mcu7t5v0__filltie
XTAP_TAPCELL_ROW_0_41 VDD VSS gf180mcu_fd_sc_mcu7t5v0__filltie
XTAP_TAPCELL_ROW_0_42 VDD VSS gf180mcu_fd_sc_mcu7t5v0__filltie
XTAP_TAPCELL_ROW_0_43 VDD VSS gf180mcu_fd_sc_mcu7t5v0__filltie
XTAP_TAPCELL_ROW_0_44 VDD VSS gf180mcu_fd_sc_mcu7t5v0__filltie
XTAP_TAPCELL_ROW_0_45 VDD VSS gf180mcu_fd_sc_mcu7t5v0__filltie
XTAP_TAPCELL_ROW_0_46 VDD VSS gf180mcu_fd_sc_mcu7t5v0__filltie
XTAP_TAPCELL_ROW_0_47 VDD VSS gf180mcu_fd_sc_mcu7t5v0__filltie
XTAP_TAPCELL_ROW_0_48 VDD VSS gf180mcu_fd_sc_mcu7t5v0__filltie
XTAP_TAPCELL_ROW_0_49 VDD VSS gf180mcu_fd_sc_mcu7t5v0__filltie
XTAP_TAPCELL_ROW_0_50 VDD VSS gf180mcu_fd_sc_mcu7t5v0__filltie
XTAP_TAPCELL_ROW_0_51 VDD VSS gf180mcu_fd_sc_mcu7t5v0__filltie
XTAP_TAPCELL_ROW_0_52 VDD VSS gf180mcu_fd_sc_mcu7t5v0__filltie
XTAP_TAPCELL_ROW_0_53 VDD VSS gf180mcu_fd_sc_mcu7t5v0__filltie
XTAP_TAPCELL_ROW_10_193 VDD VSS gf180mcu_fd_sc_mcu7t5v0__filltie
XTAP_TAPCELL_ROW_10_194 VDD VSS gf180mcu_fd_sc_mcu7t5v0__filltie
XTAP_TAPCELL_ROW_10_195 VDD VSS gf180mcu_fd_sc_mcu7t5v0__filltie
XTAP_TAPCELL_ROW_10_196 VDD VSS gf180mcu_fd_sc_mcu7t5v0__filltie
XTAP_TAPCELL_ROW_10_197 VDD VSS gf180mcu_fd_sc_mcu7t5v0__filltie
XTAP_TAPCELL_ROW_10_198 VDD VSS gf180mcu_fd_sc_mcu7t5v0__filltie
XTAP_TAPCELL_ROW_10_199 VDD VSS gf180mcu_fd_sc_mcu7t5v0__filltie
XTAP_TAPCELL_ROW_10_200 VDD VSS gf180mcu_fd_sc_mcu7t5v0__filltie
XTAP_TAPCELL_ROW_10_201 VDD VSS gf180mcu_fd_sc_mcu7t5v0__filltie
XTAP_TAPCELL_ROW_10_202 VDD VSS gf180mcu_fd_sc_mcu7t5v0__filltie
XTAP_TAPCELL_ROW_10_203 VDD VSS gf180mcu_fd_sc_mcu7t5v0__filltie
XTAP_TAPCELL_ROW_10_204 VDD VSS gf180mcu_fd_sc_mcu7t5v0__filltie
XTAP_TAPCELL_ROW_10_205 VDD VSS gf180mcu_fd_sc_mcu7t5v0__filltie
XTAP_TAPCELL_ROW_10_206 VDD VSS gf180mcu_fd_sc_mcu7t5v0__filltie
XTAP_TAPCELL_ROW_10_207 VDD VSS gf180mcu_fd_sc_mcu7t5v0__filltie
XTAP_TAPCELL_ROW_10_208 VDD VSS gf180mcu_fd_sc_mcu7t5v0__filltie
XTAP_TAPCELL_ROW_10_209 VDD VSS gf180mcu_fd_sc_mcu7t5v0__filltie
XTAP_TAPCELL_ROW_10_210 VDD VSS gf180mcu_fd_sc_mcu7t5v0__filltie
XTAP_TAPCELL_ROW_10_211 VDD VSS gf180mcu_fd_sc_mcu7t5v0__filltie
XTAP_TAPCELL_ROW_10_212 VDD VSS gf180mcu_fd_sc_mcu7t5v0__filltie
XTAP_TAPCELL_ROW_10_213 VDD VSS gf180mcu_fd_sc_mcu7t5v0__filltie
XTAP_TAPCELL_ROW_10_214 VDD VSS gf180mcu_fd_sc_mcu7t5v0__filltie
XTAP_TAPCELL_ROW_10_215 VDD VSS gf180mcu_fd_sc_mcu7t5v0__filltie
XTAP_TAPCELL_ROW_10_216 VDD VSS gf180mcu_fd_sc_mcu7t5v0__filltie
XTAP_TAPCELL_ROW_10_217 VDD VSS gf180mcu_fd_sc_mcu7t5v0__filltie
XTAP_TAPCELL_ROW_10_218 VDD VSS gf180mcu_fd_sc_mcu7t5v0__filltie
XTAP_TAPCELL_ROW_10_219 VDD VSS gf180mcu_fd_sc_mcu7t5v0__filltie
XTAP_TAPCELL_ROW_10_220 VDD VSS gf180mcu_fd_sc_mcu7t5v0__filltie
XTAP_TAPCELL_ROW_10_221 VDD VSS gf180mcu_fd_sc_mcu7t5v0__filltie
XTAP_TAPCELL_ROW_10_222 VDD VSS gf180mcu_fd_sc_mcu7t5v0__filltie
XTAP_TAPCELL_ROW_10_223 VDD VSS gf180mcu_fd_sc_mcu7t5v0__filltie
XTAP_TAPCELL_ROW_10_224 VDD VSS gf180mcu_fd_sc_mcu7t5v0__filltie
XTAP_TAPCELL_ROW_1_54 VDD VSS gf180mcu_fd_sc_mcu7t5v0__filltie
XTAP_TAPCELL_ROW_1_55 VDD VSS gf180mcu_fd_sc_mcu7t5v0__filltie
XTAP_TAPCELL_ROW_1_56 VDD VSS gf180mcu_fd_sc_mcu7t5v0__filltie
XTAP_TAPCELL_ROW_1_57 VDD VSS gf180mcu_fd_sc_mcu7t5v0__filltie
XTAP_TAPCELL_ROW_1_58 VDD VSS gf180mcu_fd_sc_mcu7t5v0__filltie
XTAP_TAPCELL_ROW_1_59 VDD VSS gf180mcu_fd_sc_mcu7t5v0__filltie
XTAP_TAPCELL_ROW_1_60 VDD VSS gf180mcu_fd_sc_mcu7t5v0__filltie
XTAP_TAPCELL_ROW_1_61 VDD VSS gf180mcu_fd_sc_mcu7t5v0__filltie
XTAP_TAPCELL_ROW_1_62 VDD VSS gf180mcu_fd_sc_mcu7t5v0__filltie
XTAP_TAPCELL_ROW_1_63 VDD VSS gf180mcu_fd_sc_mcu7t5v0__filltie
XTAP_TAPCELL_ROW_1_64 VDD VSS gf180mcu_fd_sc_mcu7t5v0__filltie
XTAP_TAPCELL_ROW_1_65 VDD VSS gf180mcu_fd_sc_mcu7t5v0__filltie
XTAP_TAPCELL_ROW_1_66 VDD VSS gf180mcu_fd_sc_mcu7t5v0__filltie
XTAP_TAPCELL_ROW_1_67 VDD VSS gf180mcu_fd_sc_mcu7t5v0__filltie
XTAP_TAPCELL_ROW_1_68 VDD VSS gf180mcu_fd_sc_mcu7t5v0__filltie
XTAP_TAPCELL_ROW_2_69 VDD VSS gf180mcu_fd_sc_mcu7t5v0__filltie
XTAP_TAPCELL_ROW_2_70 VDD VSS gf180mcu_fd_sc_mcu7t5v0__filltie
XTAP_TAPCELL_ROW_2_71 VDD VSS gf180mcu_fd_sc_mcu7t5v0__filltie
XTAP_TAPCELL_ROW_2_72 VDD VSS gf180mcu_fd_sc_mcu7t5v0__filltie
XTAP_TAPCELL_ROW_2_73 VDD VSS gf180mcu_fd_sc_mcu7t5v0__filltie
XTAP_TAPCELL_ROW_2_74 VDD VSS gf180mcu_fd_sc_mcu7t5v0__filltie
XTAP_TAPCELL_ROW_2_75 VDD VSS gf180mcu_fd_sc_mcu7t5v0__filltie
XTAP_TAPCELL_ROW_2_76 VDD VSS gf180mcu_fd_sc_mcu7t5v0__filltie
XTAP_TAPCELL_ROW_2_77 VDD VSS gf180mcu_fd_sc_mcu7t5v0__filltie
XTAP_TAPCELL_ROW_2_78 VDD VSS gf180mcu_fd_sc_mcu7t5v0__filltie
XTAP_TAPCELL_ROW_2_79 VDD VSS gf180mcu_fd_sc_mcu7t5v0__filltie
XTAP_TAPCELL_ROW_2_80 VDD VSS gf180mcu_fd_sc_mcu7t5v0__filltie
XTAP_TAPCELL_ROW_2_81 VDD VSS gf180mcu_fd_sc_mcu7t5v0__filltie
XTAP_TAPCELL_ROW_2_82 VDD VSS gf180mcu_fd_sc_mcu7t5v0__filltie
XTAP_TAPCELL_ROW_2_83 VDD VSS gf180mcu_fd_sc_mcu7t5v0__filltie
XTAP_TAPCELL_ROW_2_84 VDD VSS gf180mcu_fd_sc_mcu7t5v0__filltie
XTAP_TAPCELL_ROW_3_85 VDD VSS gf180mcu_fd_sc_mcu7t5v0__filltie
XTAP_TAPCELL_ROW_3_86 VDD VSS gf180mcu_fd_sc_mcu7t5v0__filltie
XTAP_TAPCELL_ROW_3_87 VDD VSS gf180mcu_fd_sc_mcu7t5v0__filltie
XTAP_TAPCELL_ROW_3_88 VDD VSS gf180mcu_fd_sc_mcu7t5v0__filltie
XTAP_TAPCELL_ROW_3_89 VDD VSS gf180mcu_fd_sc_mcu7t5v0__filltie
XTAP_TAPCELL_ROW_3_90 VDD VSS gf180mcu_fd_sc_mcu7t5v0__filltie
XTAP_TAPCELL_ROW_3_91 VDD VSS gf180mcu_fd_sc_mcu7t5v0__filltie
XTAP_TAPCELL_ROW_3_92 VDD VSS gf180mcu_fd_sc_mcu7t5v0__filltie
XTAP_TAPCELL_ROW_3_93 VDD VSS gf180mcu_fd_sc_mcu7t5v0__filltie
XTAP_TAPCELL_ROW_3_94 VDD VSS gf180mcu_fd_sc_mcu7t5v0__filltie
XTAP_TAPCELL_ROW_3_95 VDD VSS gf180mcu_fd_sc_mcu7t5v0__filltie
XTAP_TAPCELL_ROW_3_96 VDD VSS gf180mcu_fd_sc_mcu7t5v0__filltie
XTAP_TAPCELL_ROW_3_97 VDD VSS gf180mcu_fd_sc_mcu7t5v0__filltie
XTAP_TAPCELL_ROW_3_98 VDD VSS gf180mcu_fd_sc_mcu7t5v0__filltie
XTAP_TAPCELL_ROW_3_99 VDD VSS gf180mcu_fd_sc_mcu7t5v0__filltie
XTAP_TAPCELL_ROW_4_100 VDD VSS gf180mcu_fd_sc_mcu7t5v0__filltie
XTAP_TAPCELL_ROW_4_101 VDD VSS gf180mcu_fd_sc_mcu7t5v0__filltie
XTAP_TAPCELL_ROW_4_102 VDD VSS gf180mcu_fd_sc_mcu7t5v0__filltie
XTAP_TAPCELL_ROW_4_103 VDD VSS gf180mcu_fd_sc_mcu7t5v0__filltie
XTAP_TAPCELL_ROW_4_104 VDD VSS gf180mcu_fd_sc_mcu7t5v0__filltie
XTAP_TAPCELL_ROW_4_105 VDD VSS gf180mcu_fd_sc_mcu7t5v0__filltie
XTAP_TAPCELL_ROW_4_106 VDD VSS gf180mcu_fd_sc_mcu7t5v0__filltie
XTAP_TAPCELL_ROW_4_107 VDD VSS gf180mcu_fd_sc_mcu7t5v0__filltie
XTAP_TAPCELL_ROW_4_108 VDD VSS gf180mcu_fd_sc_mcu7t5v0__filltie
XTAP_TAPCELL_ROW_4_109 VDD VSS gf180mcu_fd_sc_mcu7t5v0__filltie
XTAP_TAPCELL_ROW_4_110 VDD VSS gf180mcu_fd_sc_mcu7t5v0__filltie
XTAP_TAPCELL_ROW_4_111 VDD VSS gf180mcu_fd_sc_mcu7t5v0__filltie
XTAP_TAPCELL_ROW_4_112 VDD VSS gf180mcu_fd_sc_mcu7t5v0__filltie
XTAP_TAPCELL_ROW_4_113 VDD VSS gf180mcu_fd_sc_mcu7t5v0__filltie
XTAP_TAPCELL_ROW_4_114 VDD VSS gf180mcu_fd_sc_mcu7t5v0__filltie
XTAP_TAPCELL_ROW_4_115 VDD VSS gf180mcu_fd_sc_mcu7t5v0__filltie
XTAP_TAPCELL_ROW_5_116 VDD VSS gf180mcu_fd_sc_mcu7t5v0__filltie
XTAP_TAPCELL_ROW_5_117 VDD VSS gf180mcu_fd_sc_mcu7t5v0__filltie
XTAP_TAPCELL_ROW_5_118 VDD VSS gf180mcu_fd_sc_mcu7t5v0__filltie
XTAP_TAPCELL_ROW_5_119 VDD VSS gf180mcu_fd_sc_mcu7t5v0__filltie
XTAP_TAPCELL_ROW_5_120 VDD VSS gf180mcu_fd_sc_mcu7t5v0__filltie
XTAP_TAPCELL_ROW_5_121 VDD VSS gf180mcu_fd_sc_mcu7t5v0__filltie
XTAP_TAPCELL_ROW_5_122 VDD VSS gf180mcu_fd_sc_mcu7t5v0__filltie
XTAP_TAPCELL_ROW_5_123 VDD VSS gf180mcu_fd_sc_mcu7t5v0__filltie
XTAP_TAPCELL_ROW_5_124 VDD VSS gf180mcu_fd_sc_mcu7t5v0__filltie
XTAP_TAPCELL_ROW_5_125 VDD VSS gf180mcu_fd_sc_mcu7t5v0__filltie
XTAP_TAPCELL_ROW_5_126 VDD VSS gf180mcu_fd_sc_mcu7t5v0__filltie
XTAP_TAPCELL_ROW_5_127 VDD VSS gf180mcu_fd_sc_mcu7t5v0__filltie
XTAP_TAPCELL_ROW_5_128 VDD VSS gf180mcu_fd_sc_mcu7t5v0__filltie
XTAP_TAPCELL_ROW_5_129 VDD VSS gf180mcu_fd_sc_mcu7t5v0__filltie
XTAP_TAPCELL_ROW_5_130 VDD VSS gf180mcu_fd_sc_mcu7t5v0__filltie
XTAP_TAPCELL_ROW_6_131 VDD VSS gf180mcu_fd_sc_mcu7t5v0__filltie
XTAP_TAPCELL_ROW_6_132 VDD VSS gf180mcu_fd_sc_mcu7t5v0__filltie
XTAP_TAPCELL_ROW_6_133 VDD VSS gf180mcu_fd_sc_mcu7t5v0__filltie
XTAP_TAPCELL_ROW_6_134 VDD VSS gf180mcu_fd_sc_mcu7t5v0__filltie
XTAP_TAPCELL_ROW_6_135 VDD VSS gf180mcu_fd_sc_mcu7t5v0__filltie
XTAP_TAPCELL_ROW_6_136 VDD VSS gf180mcu_fd_sc_mcu7t5v0__filltie
XTAP_TAPCELL_ROW_6_137 VDD VSS gf180mcu_fd_sc_mcu7t5v0__filltie
XTAP_TAPCELL_ROW_6_138 VDD VSS gf180mcu_fd_sc_mcu7t5v0__filltie
XTAP_TAPCELL_ROW_6_139 VDD VSS gf180mcu_fd_sc_mcu7t5v0__filltie
XTAP_TAPCELL_ROW_6_140 VDD VSS gf180mcu_fd_sc_mcu7t5v0__filltie
XTAP_TAPCELL_ROW_6_141 VDD VSS gf180mcu_fd_sc_mcu7t5v0__filltie
XTAP_TAPCELL_ROW_6_142 VDD VSS gf180mcu_fd_sc_mcu7t5v0__filltie
XTAP_TAPCELL_ROW_6_143 VDD VSS gf180mcu_fd_sc_mcu7t5v0__filltie
XTAP_TAPCELL_ROW_6_144 VDD VSS gf180mcu_fd_sc_mcu7t5v0__filltie
XTAP_TAPCELL_ROW_6_145 VDD VSS gf180mcu_fd_sc_mcu7t5v0__filltie
XTAP_TAPCELL_ROW_6_146 VDD VSS gf180mcu_fd_sc_mcu7t5v0__filltie
XTAP_TAPCELL_ROW_7_147 VDD VSS gf180mcu_fd_sc_mcu7t5v0__filltie
XTAP_TAPCELL_ROW_7_148 VDD VSS gf180mcu_fd_sc_mcu7t5v0__filltie
XTAP_TAPCELL_ROW_7_149 VDD VSS gf180mcu_fd_sc_mcu7t5v0__filltie
XTAP_TAPCELL_ROW_7_150 VDD VSS gf180mcu_fd_sc_mcu7t5v0__filltie
XTAP_TAPCELL_ROW_7_151 VDD VSS gf180mcu_fd_sc_mcu7t5v0__filltie
XTAP_TAPCELL_ROW_7_152 VDD VSS gf180mcu_fd_sc_mcu7t5v0__filltie
XTAP_TAPCELL_ROW_7_153 VDD VSS gf180mcu_fd_sc_mcu7t5v0__filltie
XTAP_TAPCELL_ROW_7_154 VDD VSS gf180mcu_fd_sc_mcu7t5v0__filltie
XTAP_TAPCELL_ROW_7_155 VDD VSS gf180mcu_fd_sc_mcu7t5v0__filltie
XTAP_TAPCELL_ROW_7_156 VDD VSS gf180mcu_fd_sc_mcu7t5v0__filltie
XTAP_TAPCELL_ROW_7_157 VDD VSS gf180mcu_fd_sc_mcu7t5v0__filltie
XTAP_TAPCELL_ROW_7_158 VDD VSS gf180mcu_fd_sc_mcu7t5v0__filltie
XTAP_TAPCELL_ROW_7_159 VDD VSS gf180mcu_fd_sc_mcu7t5v0__filltie
XTAP_TAPCELL_ROW_7_160 VDD VSS gf180mcu_fd_sc_mcu7t5v0__filltie
XTAP_TAPCELL_ROW_7_161 VDD VSS gf180mcu_fd_sc_mcu7t5v0__filltie
XTAP_TAPCELL_ROW_8_162 VDD VSS gf180mcu_fd_sc_mcu7t5v0__filltie
XTAP_TAPCELL_ROW_8_163 VDD VSS gf180mcu_fd_sc_mcu7t5v0__filltie
XTAP_TAPCELL_ROW_8_164 VDD VSS gf180mcu_fd_sc_mcu7t5v0__filltie
XTAP_TAPCELL_ROW_8_165 VDD VSS gf180mcu_fd_sc_mcu7t5v0__filltie
XTAP_TAPCELL_ROW_8_166 VDD VSS gf180mcu_fd_sc_mcu7t5v0__filltie
XTAP_TAPCELL_ROW_8_167 VDD VSS gf180mcu_fd_sc_mcu7t5v0__filltie
XTAP_TAPCELL_ROW_8_168 VDD VSS gf180mcu_fd_sc_mcu7t5v0__filltie
XTAP_TAPCELL_ROW_8_169 VDD VSS gf180mcu_fd_sc_mcu7t5v0__filltie
XTAP_TAPCELL_ROW_8_170 VDD VSS gf180mcu_fd_sc_mcu7t5v0__filltie
XTAP_TAPCELL_ROW_8_171 VDD VSS gf180mcu_fd_sc_mcu7t5v0__filltie
XTAP_TAPCELL_ROW_8_172 VDD VSS gf180mcu_fd_sc_mcu7t5v0__filltie
XTAP_TAPCELL_ROW_8_173 VDD VSS gf180mcu_fd_sc_mcu7t5v0__filltie
XTAP_TAPCELL_ROW_8_174 VDD VSS gf180mcu_fd_sc_mcu7t5v0__filltie
XTAP_TAPCELL_ROW_8_175 VDD VSS gf180mcu_fd_sc_mcu7t5v0__filltie
XTAP_TAPCELL_ROW_8_176 VDD VSS gf180mcu_fd_sc_mcu7t5v0__filltie
XTAP_TAPCELL_ROW_8_177 VDD VSS gf180mcu_fd_sc_mcu7t5v0__filltie
XTAP_TAPCELL_ROW_9_178 VDD VSS gf180mcu_fd_sc_mcu7t5v0__filltie
XTAP_TAPCELL_ROW_9_179 VDD VSS gf180mcu_fd_sc_mcu7t5v0__filltie
XTAP_TAPCELL_ROW_9_180 VDD VSS gf180mcu_fd_sc_mcu7t5v0__filltie
XTAP_TAPCELL_ROW_9_181 VDD VSS gf180mcu_fd_sc_mcu7t5v0__filltie
XTAP_TAPCELL_ROW_9_182 VDD VSS gf180mcu_fd_sc_mcu7t5v0__filltie
XTAP_TAPCELL_ROW_9_183 VDD VSS gf180mcu_fd_sc_mcu7t5v0__filltie
XTAP_TAPCELL_ROW_9_184 VDD VSS gf180mcu_fd_sc_mcu7t5v0__filltie
XTAP_TAPCELL_ROW_9_185 VDD VSS gf180mcu_fd_sc_mcu7t5v0__filltie
XTAP_TAPCELL_ROW_9_186 VDD VSS gf180mcu_fd_sc_mcu7t5v0__filltie
XTAP_TAPCELL_ROW_9_187 VDD VSS gf180mcu_fd_sc_mcu7t5v0__filltie
XTAP_TAPCELL_ROW_9_188 VDD VSS gf180mcu_fd_sc_mcu7t5v0__filltie
XTAP_TAPCELL_ROW_9_189 VDD VSS gf180mcu_fd_sc_mcu7t5v0__filltie
XTAP_TAPCELL_ROW_9_190 VDD VSS gf180mcu_fd_sc_mcu7t5v0__filltie
XTAP_TAPCELL_ROW_9_191 VDD VSS gf180mcu_fd_sc_mcu7t5v0__filltie
XTAP_TAPCELL_ROW_9_192 VDD VSS gf180mcu_fd_sc_mcu7t5v0__filltie
X_044_ hold_zero _010_ VDD VDD VSS VSS gf180mcu_fd_sc_mcu7t5v0__clkinv_1
X_045_ msb[4] _011_ VDD VDD VSS VSS gf180mcu_fd_sc_mcu7t5v0__clkinv_1
X_046_ msb[5] _012_ VDD VDD VSS VSS gf180mcu_fd_sc_mcu7t5v0__clkinv_1
X_047_ msb[2] _013_ VDD VDD VSS VSS gf180mcu_fd_sc_mcu7t5v0__clkinv_1
X_048_ msb[3] _014_ VDD VDD VSS VSS gf180mcu_fd_sc_mcu7t5v0__clkinv_1
X_049_ th[0] thb[0] VDD VDD VSS VSS gf180mcu_fd_sc_mcu7t5v0__clkinv_1
X_050_ th[1] thb[1] VDD VDD VSS VSS gf180mcu_fd_sc_mcu7t5v0__clkinv_1
X_051_ th[2] thb[2] VDD VDD VSS VSS gf180mcu_fd_sc_mcu7t5v0__clkinv_1
X_052_ th[3] thb[3] VDD VDD VSS VSS gf180mcu_fd_sc_mcu7t5v0__clkinv_1
X_053_ th[4] thb[4] VDD VDD VSS VSS gf180mcu_fd_sc_mcu7t5v0__clkinv_1
X_054_ th[5] thb[5] VDD VDD VSS VSS gf180mcu_fd_sc_mcu7t5v0__clkinv_1
X_055_ th[6] thb[6] VDD VDD VSS VSS gf180mcu_fd_sc_mcu7t5v0__clkinv_1
X_056_ th[7] thb[7] VDD VDD VSS VSS gf180mcu_fd_sc_mcu7t5v0__clkinv_1
X_057_ th[8] thb[8] VDD VDD VSS VSS gf180mcu_fd_sc_mcu7t5v0__clkinv_1
X_058_ th[9] thb[9] VDD VDD VSS VSS gf180mcu_fd_sc_mcu7t5v0__clkinv_1
X_059_ th[10] thb[10] VDD VDD VSS VSS gf180mcu_fd_sc_mcu7t5v0__clkinv_1
X_060_ th[11] thb[11] VDD VDD VSS VSS gf180mcu_fd_sc_mcu7t5v0__clkinv_1
X_061_ th[12] thb[12] VDD VDD VSS VSS gf180mcu_fd_sc_mcu7t5v0__clkinv_1
X_062_ th[13] thb[13] VDD VDD VSS VSS gf180mcu_fd_sc_mcu7t5v0__clkinv_1
X_063_ th[14] thb[14] VDD VDD VSS VSS gf180mcu_fd_sc_mcu7t5v0__clkinv_1
X_064_ th[15] thb[15] VDD VDD VSS VSS gf180mcu_fd_sc_mcu7t5v0__clkinv_1
X_065_ th[16] thb[16] VDD VDD VSS VSS gf180mcu_fd_sc_mcu7t5v0__clkinv_1
X_066_ th[17] thb[17] VDD VDD VSS VSS gf180mcu_fd_sc_mcu7t5v0__clkinv_1
X_067_ th[18] thb[18] VDD VDD VSS VSS gf180mcu_fd_sc_mcu7t5v0__clkinv_1
X_068_ th[19] thb[19] VDD VDD VSS VSS gf180mcu_fd_sc_mcu7t5v0__clkinv_1
X_069_ th[20] thb[20] VDD VDD VSS VSS gf180mcu_fd_sc_mcu7t5v0__clkinv_1
X_070_ th[21] thb[21] VDD VDD VSS VSS gf180mcu_fd_sc_mcu7t5v0__clkinv_1
X_071_ th[22] thb[22] VDD VDD VSS VSS gf180mcu_fd_sc_mcu7t5v0__clkinv_1
X_072_ th[23] thb[23] VDD VDD VSS VSS gf180mcu_fd_sc_mcu7t5v0__clkinv_1
X_073_ th[24] thb[24] VDD VDD VSS VSS gf180mcu_fd_sc_mcu7t5v0__clkinv_1
X_074_ th[25] thb[25] VDD VDD VSS VSS gf180mcu_fd_sc_mcu7t5v0__clkinv_1
X_075_ th[26] thb[26] VDD VDD VSS VSS gf180mcu_fd_sc_mcu7t5v0__clkinv_1
X_076_ th[27] thb[27] VDD VDD VSS VSS gf180mcu_fd_sc_mcu7t5v0__clkinv_1
X_077_ th[28] thb[28] VDD VDD VSS VSS gf180mcu_fd_sc_mcu7t5v0__clkinv_1
X_078_ th[29] thb[29] VDD VDD VSS VSS gf180mcu_fd_sc_mcu7t5v0__clkinv_1
X_079_ th[30] thb[30] VDD VDD VSS VSS gf180mcu_fd_sc_mcu7t5v0__clkinv_1
X_080_ th[31] thb[31] VDD VDD VSS VSS gf180mcu_fd_sc_mcu7t5v0__clkinv_1
X_081_ th[32] thb[32] VDD VDD VSS VSS gf180mcu_fd_sc_mcu7t5v0__clkinv_1
X_082_ th[33] thb[33] VDD VDD VSS VSS gf180mcu_fd_sc_mcu7t5v0__clkinv_1
X_083_ th[34] thb[34] VDD VDD VSS VSS gf180mcu_fd_sc_mcu7t5v0__clkinv_1
X_084_ th[35] thb[35] VDD VDD VSS VSS gf180mcu_fd_sc_mcu7t5v0__clkinv_1
X_085_ th[36] thb[36] VDD VDD VSS VSS gf180mcu_fd_sc_mcu7t5v0__clkinv_1
X_086_ th[37] thb[37] VDD VDD VSS VSS gf180mcu_fd_sc_mcu7t5v0__clkinv_1
X_087_ th[38] thb[38] VDD VDD VSS VSS gf180mcu_fd_sc_mcu7t5v0__clkinv_1
X_088_ th[39] thb[39] VDD VDD VSS VSS gf180mcu_fd_sc_mcu7t5v0__clkinv_1
X_089_ th[40] thb[40] VDD VDD VSS VSS gf180mcu_fd_sc_mcu7t5v0__clkinv_1
X_090_ th[41] thb[41] VDD VDD VSS VSS gf180mcu_fd_sc_mcu7t5v0__clkinv_1
X_091_ th[42] thb[42] VDD VDD VSS VSS gf180mcu_fd_sc_mcu7t5v0__clkinv_1
X_092_ th[43] thb[43] VDD VDD VSS VSS gf180mcu_fd_sc_mcu7t5v0__clkinv_1
X_093_ th[44] thb[44] VDD VDD VSS VSS gf180mcu_fd_sc_mcu7t5v0__clkinv_1
X_094_ th[45] thb[45] VDD VDD VSS VSS gf180mcu_fd_sc_mcu7t5v0__clkinv_1
X_095_ th[46] thb[46] VDD VDD VSS VSS gf180mcu_fd_sc_mcu7t5v0__clkinv_1
X_096_ th[47] thb[47] VDD VDD VSS VSS gf180mcu_fd_sc_mcu7t5v0__clkinv_1
X_097_ th[48] thb[48] VDD VDD VSS VSS gf180mcu_fd_sc_mcu7t5v0__clkinv_1
X_098_ th[49] thb[49] VDD VDD VSS VSS gf180mcu_fd_sc_mcu7t5v0__clkinv_1
X_099_ th[50] thb[50] VDD VDD VSS VSS gf180mcu_fd_sc_mcu7t5v0__clkinv_1
X_100_ th[51] thb[51] VDD VDD VSS VSS gf180mcu_fd_sc_mcu7t5v0__clkinv_1
X_101_ th[52] thb[52] VDD VDD VSS VSS gf180mcu_fd_sc_mcu7t5v0__clkinv_1
X_102_ th[53] thb[53] VDD VDD VSS VSS gf180mcu_fd_sc_mcu7t5v0__clkinv_1
X_103_ th[54] thb[54] VDD VDD VSS VSS gf180mcu_fd_sc_mcu7t5v0__clkinv_1
X_104_ th[55] thb[55] VDD VDD VSS VSS gf180mcu_fd_sc_mcu7t5v0__clkinv_1
X_105_ th[56] thb[56] VDD VDD VSS VSS gf180mcu_fd_sc_mcu7t5v0__clkinv_1
X_106_ th[57] thb[57] VDD VDD VSS VSS gf180mcu_fd_sc_mcu7t5v0__clkinv_1
X_107_ th[58] thb[58] VDD VDD VSS VSS gf180mcu_fd_sc_mcu7t5v0__clkinv_1
X_108_ th[59] thb[59] VDD VDD VSS VSS gf180mcu_fd_sc_mcu7t5v0__clkinv_1
X_109_ th[60] thb[60] VDD VDD VSS VSS gf180mcu_fd_sc_mcu7t5v0__clkinv_1
X_110_ th[61] thb[61] VDD VDD VSS VSS gf180mcu_fd_sc_mcu7t5v0__clkinv_1
X_111_ th[62] thb[62] VDD VDD VSS VSS gf180mcu_fd_sc_mcu7t5v0__clkinv_1
X_112_ bn[0] bnb[0] VDD VDD VSS VSS gf180mcu_fd_sc_mcu7t5v0__clkinv_1
X_113_ bn[1] bnb[1] VDD VDD VSS VSS gf180mcu_fd_sc_mcu7t5v0__clkinv_1
X_114_ bn[2] bnb[2] VDD VDD VSS VSS gf180mcu_fd_sc_mcu7t5v0__clkinv_1
X_115_ bn[3] bnb[3] VDD VDD VSS VSS gf180mcu_fd_sc_mcu7t5v0__clkinv_1
X_116_ en load_en_b VDD VDD VSS VSS gf180mcu_fd_sc_mcu7t5v0__clkinv_1
X_117_ code_tc[1] _010_ _001_ VDD VDD VSS VSS gf180mcu_fd_sc_mcu7t5v0__and2_1
X_118_ _010_ code_tc[2] _002_ VDD VDD VSS VSS gf180mcu_fd_sc_mcu7t5v0__and2_1
X_119_ _010_ code_tc[3] _003_ VDD VDD VSS VSS gf180mcu_fd_sc_mcu7t5v0__and2_1
X_120_ _010_ code_tc[4] _004_ VDD VDD VSS VSS gf180mcu_fd_sc_mcu7t5v0__and2_1
X_121_ _010_ code_tc[5] _005_ VDD VDD VSS VSS gf180mcu_fd_sc_mcu7t5v0__and2_1
X_122_ _010_ code_tc[6] _006_ VDD VDD VSS VSS gf180mcu_fd_sc_mcu7t5v0__and2_1
X_123_ _010_ code_tc[7] _007_ VDD VDD VSS VSS gf180mcu_fd_sc_mcu7t5v0__and2_1
X_124_ _010_ code_tc[8] _008_ VDD VDD VSS VSS gf180mcu_fd_sc_mcu7t5v0__and2_1
X_125_ _010_ code_tc[9] _009_ VDD VDD VSS VSS gf180mcu_fd_sc_mcu7t5v0__nand2_1
X_126_ msb[4] msb[5] _015_ VDD VDD VSS VSS gf180mcu_fd_sc_mcu7t5v0__nor2_1
X_127_ _015_ therm[15] VDD VDD VSS VSS gf180mcu_fd_sc_mcu7t5v0__clkinv_1
X_128_ msb[4] msb[3] _016_ VDD VDD VSS VSS gf180mcu_fd_sc_mcu7t5v0__nor2_1
X_129_ msb[5] msb[2] _017_ VDD VDD VSS VSS gf180mcu_fd_sc_mcu7t5v0__nor2_1
X_130_ msb[2] msb[3] _018_ VDD VDD VSS VSS gf180mcu_fd_sc_mcu7t5v0__nor2_1
X_131_ _015_ _018_ therm[3] VDD VDD VSS VSS gf180mcu_fd_sc_mcu7t5v0__nand2_1
X_132_ msb[0] msb[1] _019_ VDD VDD VSS VSS gf180mcu_fd_sc_mcu7t5v0__nor2_1
X_133_ msb[0] msb[1] _020_ VDD VDD VSS VSS gf180mcu_fd_sc_mcu7t5v0__or2_1
X_134_ msb[3] _020_ _021_ VDD VDD VSS VSS gf180mcu_fd_sc_mcu7t5v0__nor2_1
X_135_ msb[2] _020_ msb[3] _022_ VDD VDD VSS VSS gf180mcu_fd_sc_mcu7t5v0__aoi21_1
X_136_ _015_ _022_ therm[4] VDD VDD VSS VSS gf180mcu_fd_sc_mcu7t5v0__nand2_1
X_137_ msb[2] msb[1] msb[3] _023_ VDD VDD VSS VSS gf180mcu_fd_sc_mcu7t5v0__aoi21_1
X_138_ _015_ _023_ therm[5] VDD VDD VSS VSS gf180mcu_fd_sc_mcu7t5v0__nand2_1
X_139_ msb[0] msb[1] _024_ VDD VDD VSS VSS gf180mcu_fd_sc_mcu7t5v0__and2_1
X_140_ msb[0] msb[1] _025_ VDD VDD VSS VSS gf180mcu_fd_sc_mcu7t5v0__nand2_1
X_141_ _014_ _015_ therm[7] VDD VDD VSS VSS gf180mcu_fd_sc_mcu7t5v0__nand2_1
X_142_ msb[3] _024_ _026_ VDD VDD VSS VSS gf180mcu_fd_sc_mcu7t5v0__nor2_1
X_143_ msb[2] _024_ msb[3] _027_ VDD VDD VSS VSS gf180mcu_fd_sc_mcu7t5v0__aoi21_1
X_144_ _015_ _027_ therm[6] VDD VDD VSS VSS gf180mcu_fd_sc_mcu7t5v0__nand2_1
X_145_ msb[2] msb[1] _028_ VDD VDD VSS VSS gf180mcu_fd_sc_mcu7t5v0__nor2_1
X_146_ msb[5] msb[2] msb[1] _029_ VDD VDD VSS VSS gf180mcu_fd_sc_mcu7t5v0__nor3_1
X_147_ msb[2] _020_ _030_ VDD VDD VSS VSS gf180mcu_fd_sc_mcu7t5v0__nor2_1
X_148_ _014_ _030_ _015_ therm[8] VDD VDD VSS VSS gf180mcu_fd_sc_mcu7t5v0__oai21_1
X_149_ _014_ _028_ _015_ therm[9] VDD VDD VSS VSS gf180mcu_fd_sc_mcu7t5v0__oai21_1
X_150_ msb[2] msb[3] _031_ VDD VDD VSS VSS gf180mcu_fd_sc_mcu7t5v0__and2_1
X_151_ msb[2] msb[3] _032_ VDD VDD VSS VSS gf180mcu_fd_sc_mcu7t5v0__nand2_1
X_152_ _015_ _032_ therm[11] VDD VDD VSS VSS gf180mcu_fd_sc_mcu7t5v0__nand2_1
X_153_ msb[2] _024_ msb[3] _033_ VDD VDD VSS VSS gf180mcu_fd_sc_mcu7t5v0__oai21_1
X_154_ _015_ _033_ therm[10] VDD VDD VSS VSS gf180mcu_fd_sc_mcu7t5v0__nand2_1
X_155_ _020_ _031_ _034_ VDD VDD VSS VSS gf180mcu_fd_sc_mcu7t5v0__nand2_1
X_156_ _015_ _034_ therm[12] VDD VDD VSS VSS gf180mcu_fd_sc_mcu7t5v0__nand2_1
X_157_ msb[1] _031_ _035_ VDD VDD VSS VSS gf180mcu_fd_sc_mcu7t5v0__nand2_1
X_158_ _015_ _035_ therm[13] VDD VDD VSS VSS gf180mcu_fd_sc_mcu7t5v0__nand2_1
X_159_ _024_ _031_ _036_ VDD VDD VSS VSS gf180mcu_fd_sc_mcu7t5v0__nand2_1
X_160_ _015_ _036_ therm[14] VDD VDD VSS VSS gf180mcu_fd_sc_mcu7t5v0__nand2_1
X_161_ _017_ _021_ _015_ therm[16] VDD VDD VSS VSS gf180mcu_fd_sc_mcu7t5v0__aoi21_1
X_162_ _014_ _029_ _015_ therm[17] VDD VDD VSS VSS gf180mcu_fd_sc_mcu7t5v0__aoi21_1
X_163_ _011_ _018_ _012_ therm[19] VDD VDD VSS VSS gf180mcu_fd_sc_mcu7t5v0__oai21_1
X_164_ _017_ _026_ _015_ therm[18] VDD VDD VSS VSS gf180mcu_fd_sc_mcu7t5v0__aoi21_1
X_165_ _011_ _022_ _012_ therm[20] VDD VDD VSS VSS gf180mcu_fd_sc_mcu7t5v0__oai21_1
X_166_ _011_ _023_ _012_ therm[21] VDD VDD VSS VSS gf180mcu_fd_sc_mcu7t5v0__oai21_1
X_167_ _011_ _027_ _012_ therm[22] VDD VDD VSS VSS gf180mcu_fd_sc_mcu7t5v0__oai21_1
X_168_ msb[4] msb[3] msb[5] _037_ VDD VDD VSS VSS gf180mcu_fd_sc_mcu7t5v0__aoi21_1
X_169_ _037_ therm[23] VDD VDD VSS VSS gf180mcu_fd_sc_mcu7t5v0__clkinv_1
X_170_ _017_ _019_ _037_ therm[24] VDD VDD VSS VSS gf180mcu_fd_sc_mcu7t5v0__aoi21_1
X_171_ _029_ _037_ therm[25] VDD VDD VSS VSS gf180mcu_fd_sc_mcu7t5v0__nor2_1
X_172_ _011_ _033_ _012_ therm[26] VDD VDD VSS VSS gf180mcu_fd_sc_mcu7t5v0__oai21_1
X_173_ _011_ _013_ _014_ _012_ therm[27] VDD VDD VSS VSS gf180mcu_fd_sc_mcu7t5v0__oai31_1
X_174_ _011_ _034_ _012_ therm[28] VDD VDD VSS VSS gf180mcu_fd_sc_mcu7t5v0__oai21_1
X_175_ msb[4] msb[2] msb[3] _038_ VDD VDD VSS VSS gf180mcu_fd_sc_mcu7t5v0__and3_1
X_176_ _011_ _035_ _012_ therm[29] VDD VDD VSS VSS gf180mcu_fd_sc_mcu7t5v0__oai21_1
X_177_ _024_ _038_ msb[5] _039_ VDD VDD VSS VSS gf180mcu_fd_sc_mcu7t5v0__aoi21_1
X_178_ _039_ therm[30] VDD VDD VSS VSS gf180mcu_fd_sc_mcu7t5v0__clkinv_1
X_179_ msb[4] msb[5] _040_ VDD VDD VSS VSS gf180mcu_fd_sc_mcu7t5v0__nand2_1
X_180_ _040_ therm[47] VDD VDD VSS VSS gf180mcu_fd_sc_mcu7t5v0__clkinv_1
X_181_ msb[2] msb[3] msb[5] _041_ VDD VDD VSS VSS gf180mcu_fd_sc_mcu7t5v0__oai21_1
X_182_ msb[4] msb[3] msb[5] _042_ VDD VDD VSS VSS gf180mcu_fd_sc_mcu7t5v0__oai21_1
X_183_ _042_ therm[39] VDD VDD VSS VSS gf180mcu_fd_sc_mcu7t5v0__clkinv_1
X_184_ _040_ _041_ therm[35] VDD VDD VSS VSS gf180mcu_fd_sc_mcu7t5v0__nand2_1
X_185_ _012_ _019_ _040_ _041_ therm[32] VDD VDD VSS VSS gf180mcu_fd_sc_mcu7t5v0__oai211_1
X_186_ _016_ _028_ _012_ therm[33] VDD VDD VSS VSS gf180mcu_fd_sc_mcu7t5v0__aoi21_1
X_187_ _012_ _025_ _040_ _041_ therm[34] VDD VDD VSS VSS gf180mcu_fd_sc_mcu7t5v0__oai211_1
X_188_ _011_ _022_ _012_ therm[36] VDD VDD VSS VSS gf180mcu_fd_sc_mcu7t5v0__aoi21_1
X_189_ _011_ _023_ _012_ therm[37] VDD VDD VSS VSS gf180mcu_fd_sc_mcu7t5v0__aoi21_1
X_190_ _011_ _027_ _012_ therm[38] VDD VDD VSS VSS gf180mcu_fd_sc_mcu7t5v0__aoi21_1
X_191_ _011_ _028_ _042_ therm[41] VDD VDD VSS VSS gf180mcu_fd_sc_mcu7t5v0__aoi21_1
X_192_ _011_ _030_ _042_ therm[40] VDD VDD VSS VSS gf180mcu_fd_sc_mcu7t5v0__aoi21_1
X_193_ _011_ _033_ _012_ therm[42] VDD VDD VSS VSS gf180mcu_fd_sc_mcu7t5v0__aoi21_1
X_194_ _011_ _032_ _012_ therm[43] VDD VDD VSS VSS gf180mcu_fd_sc_mcu7t5v0__aoi21_1
X_195_ _011_ _034_ _012_ therm[44] VDD VDD VSS VSS gf180mcu_fd_sc_mcu7t5v0__aoi21_1
X_196_ _011_ _035_ _012_ therm[45] VDD VDD VSS VSS gf180mcu_fd_sc_mcu7t5v0__aoi21_1
X_197_ _011_ _036_ _012_ therm[46] VDD VDD VSS VSS gf180mcu_fd_sc_mcu7t5v0__aoi21_1
X_198_ msb[3] therm[47] _043_ VDD VDD VSS VSS gf180mcu_fd_sc_mcu7t5v0__nand2_1
X_199_ _043_ therm[55] VDD VDD VSS VSS gf180mcu_fd_sc_mcu7t5v0__clkinv_1
X_200_ _018_ _019_ _040_ therm[48] VDD VDD VSS VSS gf180mcu_fd_sc_mcu7t5v0__aoi21_1
X_201_ _018_ _040_ therm[51] VDD VDD VSS VSS gf180mcu_fd_sc_mcu7t5v0__nor2_1
X_202_ _014_ _028_ _040_ therm[49] VDD VDD VSS VSS gf180mcu_fd_sc_mcu7t5v0__aoi21_1
X_203_ _018_ _025_ _040_ therm[50] VDD VDD VSS VSS gf180mcu_fd_sc_mcu7t5v0__aoi21_1
X_204_ _022_ _040_ therm[52] VDD VDD VSS VSS gf180mcu_fd_sc_mcu7t5v0__nor2_1
X_205_ _023_ _040_ therm[53] VDD VDD VSS VSS gf180mcu_fd_sc_mcu7t5v0__nor2_1
X_206_ _027_ _040_ therm[54] VDD VDD VSS VSS gf180mcu_fd_sc_mcu7t5v0__nor2_1
X_207_ _030_ _043_ therm[56] VDD VDD VSS VSS gf180mcu_fd_sc_mcu7t5v0__nor2_1
X_208_ _028_ _043_ therm[57] VDD VDD VSS VSS gf180mcu_fd_sc_mcu7t5v0__nor2_1
X_209_ _033_ _040_ therm[58] VDD VDD VSS VSS gf180mcu_fd_sc_mcu7t5v0__nor2_1
X_210_ _032_ _040_ therm[59] VDD VDD VSS VSS gf180mcu_fd_sc_mcu7t5v0__nor2_1
X_211_ _034_ _040_ therm[60] VDD VDD VSS VSS gf180mcu_fd_sc_mcu7t5v0__nor2_1
X_212_ _035_ _040_ therm[61] VDD VDD VSS VSS gf180mcu_fd_sc_mcu7t5v0__nor2_1
X_213_ _036_ _040_ therm[62] VDD VDD VSS VSS gf180mcu_fd_sc_mcu7t5v0__nor2_1
X_214_ _015_ _018_ _019_ therm[0] VDD VDD VSS VSS gf180mcu_fd_sc_mcu7t5v0__nand3_1
X_215_ _016_ _029_ therm[1] VDD VDD VSS VSS gf180mcu_fd_sc_mcu7t5v0__nand2_1
X_216_ _015_ _018_ _025_ therm[2] VDD VDD VSS VSS gf180mcu_fd_sc_mcu7t5v0__nand3_1
X_217_ _010_ code_tc[0] _000_ VDD VDD VSS VSS gf180mcu_fd_sc_mcu7t5v0__and2_1
X_218_ msb[5] therm[31] VDD VDD VSS VSS gf180mcu_fd_sc_mcu7t5v0__buf_1
X_219_ therm[0] en clknet_4_4__leaf_clk th[0] VDD VDD VSS VSS gf180mcu_fd_sc_mcu7t5v0__dffrnq_1
X_220_ therm[1] en clknet_4_4__leaf_clk th[1] VDD VDD VSS VSS gf180mcu_fd_sc_mcu7t5v0__dffrnq_1
X_221_ therm[2] en clknet_4_1__leaf_clk th[2] VDD VDD VSS VSS gf180mcu_fd_sc_mcu7t5v0__dffrnq_1
X_222_ therm[3] en clknet_4_0__leaf_clk th[3] VDD VDD VSS VSS gf180mcu_fd_sc_mcu7t5v0__dffrnq_1
X_223_ therm[4] en clknet_4_0__leaf_clk th[4] VDD VDD VSS VSS gf180mcu_fd_sc_mcu7t5v0__dffrnq_1
X_224_ therm[5] en clknet_4_1__leaf_clk th[5] VDD VDD VSS VSS gf180mcu_fd_sc_mcu7t5v0__dffrnq_1
X_225_ therm[6] en clknet_4_4__leaf_clk th[6] VDD VDD VSS VSS gf180mcu_fd_sc_mcu7t5v0__dffrnq_1
X_226_ therm[7] en clknet_4_0__leaf_clk th[7] VDD VDD VSS VSS gf180mcu_fd_sc_mcu7t5v0__dffrnq_1
X_227_ therm[8] en clknet_4_0__leaf_clk th[8] VDD VDD VSS VSS gf180mcu_fd_sc_mcu7t5v0__dffrnq_1
X_228_ therm[9] en clknet_4_4__leaf_clk th[9] VDD VDD VSS VSS gf180mcu_fd_sc_mcu7t5v0__dffrnq_1
X_229_ therm[10] en clknet_4_1__leaf_clk th[10] VDD VDD VSS VSS gf180mcu_fd_sc_mcu7t5v0__dffrnq_1
X_230_ therm[11] en clknet_4_1__leaf_clk th[11] VDD VDD VSS VSS gf180mcu_fd_sc_mcu7t5v0__dffrnq_1
X_231_ therm[12] en clknet_4_4__leaf_clk th[12] VDD VDD VSS VSS gf180mcu_fd_sc_mcu7t5v0__dffrnq_1
X_232_ therm[13] en clknet_4_1__leaf_clk th[13] VDD VDD VSS VSS gf180mcu_fd_sc_mcu7t5v0__dffrnq_1
X_233_ therm[14] en clknet_4_0__leaf_clk th[14] VDD VDD VSS VSS gf180mcu_fd_sc_mcu7t5v0__dffrnq_1
X_234_ therm[15] en clknet_4_5__leaf_clk th[15] VDD VDD VSS VSS gf180mcu_fd_sc_mcu7t5v0__dffrnq_1
X_235_ therm[16] en clknet_4_5__leaf_clk th[16] VDD VDD VSS VSS gf180mcu_fd_sc_mcu7t5v0__dffrnq_1
X_236_ therm[17] en clknet_4_5__leaf_clk th[17] VDD VDD VSS VSS gf180mcu_fd_sc_mcu7t5v0__dffrnq_1
X_237_ therm[18] en clknet_4_5__leaf_clk th[18] VDD VDD VSS VSS gf180mcu_fd_sc_mcu7t5v0__dffrnq_1
X_238_ therm[19] en clknet_4_3__leaf_clk th[19] VDD VDD VSS VSS gf180mcu_fd_sc_mcu7t5v0__dffrnq_1
X_239_ therm[20] en clknet_4_5__leaf_clk th[20] VDD VDD VSS VSS gf180mcu_fd_sc_mcu7t5v0__dffrnq_1
X_240_ therm[21] en clknet_4_7__leaf_clk th[21] VDD VDD VSS VSS gf180mcu_fd_sc_mcu7t5v0__dffrnq_1
X_241_ therm[22] en clknet_4_3__leaf_clk th[22] VDD VDD VSS VSS gf180mcu_fd_sc_mcu7t5v0__dffrnq_1
X_242_ therm[23] en clknet_4_7__leaf_clk th[23] VDD VDD VSS VSS gf180mcu_fd_sc_mcu7t5v0__dffrnq_1
X_243_ therm[24] en clknet_4_7__leaf_clk th[24] VDD VDD VSS VSS gf180mcu_fd_sc_mcu7t5v0__dffrnq_1
X_244_ therm[25] en clknet_4_7__leaf_clk th[25] VDD VDD VSS VSS gf180mcu_fd_sc_mcu7t5v0__dffrnq_1
X_245_ therm[26] en clknet_4_3__leaf_clk th[26] VDD VDD VSS VSS gf180mcu_fd_sc_mcu7t5v0__dffrnq_1
X_246_ therm[27] en clknet_4_6__leaf_clk th[27] VDD VDD VSS VSS gf180mcu_fd_sc_mcu7t5v0__dffrnq_1
X_247_ therm[28] en clknet_4_3__leaf_clk th[28] VDD VDD VSS VSS gf180mcu_fd_sc_mcu7t5v0__dffrnq_1
X_248_ therm[29] en clknet_4_3__leaf_clk th[29] VDD VDD VSS VSS gf180mcu_fd_sc_mcu7t5v0__dffrnq_1
X_249_ therm[30] en clknet_4_6__leaf_clk th[30] VDD VDD VSS VSS gf180mcu_fd_sc_mcu7t5v0__dffrnq_1
X_250_ therm[31] en clknet_4_2__leaf_clk th[31] VDD VDD VSS VSS gf180mcu_fd_sc_mcu7t5v0__dffrnq_1
X_251_ therm[32] en clknet_4_2__leaf_clk th[32] VDD VDD VSS VSS gf180mcu_fd_sc_mcu7t5v0__dffrnq_1
X_252_ therm[33] en clknet_4_6__leaf_clk th[33] VDD VDD VSS VSS gf180mcu_fd_sc_mcu7t5v0__dffrnq_1
X_253_ therm[34] en clknet_4_6__leaf_clk th[34] VDD VDD VSS VSS gf180mcu_fd_sc_mcu7t5v0__dffrnq_1
X_254_ therm[35] en clknet_4_2__leaf_clk th[35] VDD VDD VSS VSS gf180mcu_fd_sc_mcu7t5v0__dffrnq_1
X_255_ therm[36] en clknet_4_2__leaf_clk th[36] VDD VDD VSS VSS gf180mcu_fd_sc_mcu7t5v0__dffrnq_1
X_256_ therm[37] en clknet_4_6__leaf_clk th[37] VDD VDD VSS VSS gf180mcu_fd_sc_mcu7t5v0__dffrnq_1
X_257_ therm[38] en clknet_4_2__leaf_clk th[38] VDD VDD VSS VSS gf180mcu_fd_sc_mcu7t5v0__dffrnq_1
X_258_ therm[39] en clknet_4_9__leaf_clk th[39] VDD VDD VSS VSS gf180mcu_fd_sc_mcu7t5v0__dffrnq_1
X_259_ therm[40] en clknet_4_9__leaf_clk th[40] VDD VDD VSS VSS gf180mcu_fd_sc_mcu7t5v0__dffrnq_1
X_260_ therm[41] en clknet_4_9__leaf_clk th[41] VDD VDD VSS VSS gf180mcu_fd_sc_mcu7t5v0__dffrnq_1
X_261_ therm[42] en clknet_4_9__leaf_clk th[42] VDD VDD VSS VSS gf180mcu_fd_sc_mcu7t5v0__dffrnq_1
X_262_ therm[43] en clknet_4_9__leaf_clk th[43] VDD VDD VSS VSS gf180mcu_fd_sc_mcu7t5v0__dffrnq_1
X_263_ therm[44] en clknet_4_8__leaf_clk th[44] VDD VDD VSS VSS gf180mcu_fd_sc_mcu7t5v0__dffrnq_1
X_264_ therm[45] en clknet_4_8__leaf_clk th[45] VDD VDD VSS VSS gf180mcu_fd_sc_mcu7t5v0__dffrnq_1
X_265_ therm[46] en clknet_4_8__leaf_clk th[46] VDD VDD VSS VSS gf180mcu_fd_sc_mcu7t5v0__dffrnq_1
X_266_ therm[47] en clknet_4_11__leaf_clk th[47] VDD VDD VSS VSS gf180mcu_fd_sc_mcu7t5v0__dffrnq_1
X_267_ therm[48] en clknet_4_12__leaf_clk th[48] VDD VDD VSS VSS gf180mcu_fd_sc_mcu7t5v0__dffrnq_1
X_268_ therm[49] en clknet_4_13__leaf_clk th[49] VDD VDD VSS VSS gf180mcu_fd_sc_mcu7t5v0__dffrnq_1
X_269_ therm[50] en clknet_4_12__leaf_clk th[50] VDD VDD VSS VSS gf180mcu_fd_sc_mcu7t5v0__dffrnq_1
X_270_ therm[51] en clknet_4_8__leaf_clk th[51] VDD VDD VSS VSS gf180mcu_fd_sc_mcu7t5v0__dffrnq_1
X_271_ therm[52] en clknet_4_13__leaf_clk th[52] VDD VDD VSS VSS gf180mcu_fd_sc_mcu7t5v0__dffrnq_1
X_272_ therm[53] en clknet_4_14__leaf_clk th[53] VDD VDD VSS VSS gf180mcu_fd_sc_mcu7t5v0__dffrnq_1
X_273_ therm[54] en clknet_4_8__leaf_clk th[54] VDD VDD VSS VSS gf180mcu_fd_sc_mcu7t5v0__dffrnq_1
X_274_ therm[55] en clknet_4_10__leaf_clk th[55] VDD VDD VSS VSS gf180mcu_fd_sc_mcu7t5v0__dffrnq_1
X_275_ therm[56] en clknet_4_10__leaf_clk th[56] VDD VDD VSS VSS gf180mcu_fd_sc_mcu7t5v0__dffrnq_1
X_276_ therm[57] en clknet_4_14__leaf_clk th[57] VDD VDD VSS VSS gf180mcu_fd_sc_mcu7t5v0__dffrnq_1
X_277_ therm[58] en clknet_4_11__leaf_clk th[58] VDD VDD VSS VSS gf180mcu_fd_sc_mcu7t5v0__dffrnq_1
X_278_ therm[59] en clknet_4_11__leaf_clk th[59] VDD VDD VSS VSS gf180mcu_fd_sc_mcu7t5v0__dffrnq_1
X_279_ therm[60] en clknet_4_10__leaf_clk th[60] VDD VDD VSS VSS gf180mcu_fd_sc_mcu7t5v0__dffrnq_1
X_280_ therm[61] en clknet_4_14__leaf_clk th[61] VDD VDD VSS VSS gf180mcu_fd_sc_mcu7t5v0__dffrnq_1
X_281_ therm[62] en clknet_4_10__leaf_clk th[62] VDD VDD VSS VSS gf180mcu_fd_sc_mcu7t5v0__dffrnq_1
X_282_ ob[0] en clknet_4_14__leaf_clk bn[0] VDD VDD VSS VSS gf180mcu_fd_sc_mcu7t5v0__dffrnq_1
X_283_ ob[1] en clknet_4_10__leaf_clk bn[1] VDD VDD VSS VSS gf180mcu_fd_sc_mcu7t5v0__dffrnq_1
X_284_ ob[2] en clknet_4_11__leaf_clk bn[2] VDD VDD VSS VSS gf180mcu_fd_sc_mcu7t5v0__dffrnq_1
X_285_ ob[3] en clknet_4_14__leaf_clk bn[3] VDD VDD VSS VSS gf180mcu_fd_sc_mcu7t5v0__dffrnq_1
X_286_ _000_ en clknet_4_15__leaf_clk ob[0] VDD VDD VSS VSS gf180mcu_fd_sc_mcu7t5v0__dffrnq_1
X_287_ _001_ en clknet_4_15__leaf_clk ob[1] VDD VDD VSS VSS gf180mcu_fd_sc_mcu7t5v0__dffrnq_1
X_288_ _002_ en clknet_4_15__leaf_clk ob[2] VDD VDD VSS VSS gf180mcu_fd_sc_mcu7t5v0__dffrnq_1
X_289_ _003_ en clknet_4_15__leaf_clk ob[3] VDD VDD VSS VSS gf180mcu_fd_sc_mcu7t5v0__dffrnq_1
X_290_ _004_ en clknet_4_12__leaf_clk msb[0] VDD VDD VSS VSS gf180mcu_fd_sc_mcu7t5v0__dffrnq_1
X_291_ _005_ en clknet_4_12__leaf_clk msb[1] VDD VDD VSS VSS gf180mcu_fd_sc_mcu7t5v0__dffrnq_1
X_292_ _006_ en clknet_4_13__leaf_clk msb[2] VDD VDD VSS VSS gf180mcu_fd_sc_mcu7t5v0__dffrnq_1
X_293_ _007_ en clknet_4_13__leaf_clk msb[3] VDD VDD VSS VSS gf180mcu_fd_sc_mcu7t5v0__dffrnq_1
X_294_ _008_ en clknet_4_12__leaf_clk msb[4] VDD VDD VSS VSS gf180mcu_fd_sc_mcu7t5v0__dffrnq_1
X_295_ _009_ en clknet_4_13__leaf_clk msb[5] VDD VDD VSS VSS gf180mcu_fd_sc_mcu7t5v0__dffsnq_1
X_296_ en out_en VDD VDD VSS VSS gf180mcu_fd_sc_mcu7t5v0__buf_1
Xclkbuf_0_clk clk clknet_0_clk VDD VDD VSS VSS gf180mcu_fd_sc_mcu7t5v0__clkbuf_16
Xclkbuf_3_0_0_clk clknet_0_clk clknet_3_0_0_clk VDD VDD VSS VSS gf180mcu_fd_sc_mcu7t5v0__clkbuf_8
Xclkbuf_3_1_0_clk clknet_0_clk clknet_3_1_0_clk VDD VDD VSS VSS gf180mcu_fd_sc_mcu7t5v0__clkbuf_8
Xclkbuf_3_2_0_clk clknet_0_clk clknet_3_2_0_clk VDD VDD VSS VSS gf180mcu_fd_sc_mcu7t5v0__clkbuf_8
Xclkbuf_3_3_0_clk clknet_0_clk clknet_3_3_0_clk VDD VDD VSS VSS gf180mcu_fd_sc_mcu7t5v0__clkbuf_8
Xclkbuf_3_4_0_clk clknet_0_clk clknet_3_4_0_clk VDD VDD VSS VSS gf180mcu_fd_sc_mcu7t5v0__clkbuf_8
Xclkbuf_3_5_0_clk clknet_0_clk clknet_3_5_0_clk VDD VDD VSS VSS gf180mcu_fd_sc_mcu7t5v0__clkbuf_8
Xclkbuf_3_6_0_clk clknet_0_clk clknet_3_6_0_clk VDD VDD VSS VSS gf180mcu_fd_sc_mcu7t5v0__clkbuf_8
Xclkbuf_3_7_0_clk clknet_0_clk clknet_3_7_0_clk VDD VDD VSS VSS gf180mcu_fd_sc_mcu7t5v0__clkbuf_8
Xclkbuf_4_0__f_clk clknet_3_0_0_clk clknet_4_0__leaf_clk VDD VDD VSS VSS gf180mcu_fd_sc_mcu7t5v0__clkbuf_16
Xclkbuf_4_10__f_clk clknet_3_5_0_clk clknet_4_10__leaf_clk VDD VDD VSS VSS gf180mcu_fd_sc_mcu7t5v0__clkbuf_16
Xclkbuf_4_11__f_clk clknet_3_5_0_clk clknet_4_11__leaf_clk VDD VDD VSS VSS gf180mcu_fd_sc_mcu7t5v0__clkbuf_16
Xclkbuf_4_12__f_clk clknet_3_6_0_clk clknet_4_12__leaf_clk VDD VDD VSS VSS gf180mcu_fd_sc_mcu7t5v0__clkbuf_16
Xclkbuf_4_13__f_clk clknet_3_6_0_clk clknet_4_13__leaf_clk VDD VDD VSS VSS gf180mcu_fd_sc_mcu7t5v0__clkbuf_16
Xclkbuf_4_14__f_clk clknet_3_7_0_clk clknet_4_14__leaf_clk VDD VDD VSS VSS gf180mcu_fd_sc_mcu7t5v0__clkbuf_16
Xclkbuf_4_15__f_clk clknet_3_7_0_clk clknet_4_15__leaf_clk VDD VDD VSS VSS gf180mcu_fd_sc_mcu7t5v0__clkbuf_16
Xclkbuf_4_1__f_clk clknet_3_0_0_clk clknet_4_1__leaf_clk VDD VDD VSS VSS gf180mcu_fd_sc_mcu7t5v0__clkbuf_16
Xclkbuf_4_2__f_clk clknet_3_1_0_clk clknet_4_2__leaf_clk VDD VDD VSS VSS gf180mcu_fd_sc_mcu7t5v0__clkbuf_16
Xclkbuf_4_3__f_clk clknet_3_1_0_clk clknet_4_3__leaf_clk VDD VDD VSS VSS gf180mcu_fd_sc_mcu7t5v0__clkbuf_16
Xclkbuf_4_4__f_clk clknet_3_2_0_clk clknet_4_4__leaf_clk VDD VDD VSS VSS gf180mcu_fd_sc_mcu7t5v0__clkbuf_16
Xclkbuf_4_5__f_clk clknet_3_2_0_clk clknet_4_5__leaf_clk VDD VDD VSS VSS gf180mcu_fd_sc_mcu7t5v0__clkbuf_16
Xclkbuf_4_6__f_clk clknet_3_3_0_clk clknet_4_6__leaf_clk VDD VDD VSS VSS gf180mcu_fd_sc_mcu7t5v0__clkbuf_16
Xclkbuf_4_7__f_clk clknet_3_3_0_clk clknet_4_7__leaf_clk VDD VDD VSS VSS gf180mcu_fd_sc_mcu7t5v0__clkbuf_16
Xclkbuf_4_8__f_clk clknet_3_4_0_clk clknet_4_8__leaf_clk VDD VDD VSS VSS gf180mcu_fd_sc_mcu7t5v0__clkbuf_16
Xclkbuf_4_9__f_clk clknet_3_4_0_clk clknet_4_9__leaf_clk VDD VDD VSS VSS gf180mcu_fd_sc_mcu7t5v0__clkbuf_16
Xclkload0 clknet_4_7__leaf_clk nc_clkload0_Z VDD VDD VSS VSS gf180mcu_fd_sc_mcu7t5v0__clkbuf_2
Xclkload1 clknet_4_11__leaf_clk nc_clkload1_Z VDD VDD VSS VSS gf180mcu_fd_sc_mcu7t5v0__clkbuf_2
Xclkload2 clknet_4_12__leaf_clk nc_clkload2_Z VDD VDD VSS VSS gf180mcu_fd_sc_mcu7t5v0__clkbuf_2
Xclkload3 clknet_4_15__leaf_clk nc_clkload3_Z VDD VDD VSS VSS gf180mcu_fd_sc_mcu7t5v0__clkbuf_2
.ends

.subckt pt_dac_q VDD VSS OUTP OUTN IBIAS CLK EN HOLD_ZERO CODE0 CODE1 CODE2 CODE3 CODE4 CODE5 CODE6 CODE7 CODE8 CODE9 ATB_BIAS
XXL CK EN HOLD_ZERO LOAD_ENB OUT_EN VDD VSS BN0 BN1 BN2 BN3 BNB0 BNB1 BNB2 BNB3 CODE0 CODE1 CODE2 CODE3 CODE4 CODE5 CODE6 CODE7 CODE8 CODE9 TH0 TH1 TH2 TH3 TH4 TH5 TH6 TH7 TH8 TH9 TH10 TH11 TH12 TH13 TH14 TH15 TH16 TH17 TH18 TH19 TH20 TH21 TH22 TH23 TH24 TH25 TH26 TH27 TH28 TH29 TH30 TH31 TH32 TH33 TH34 TH35 TH36 TH37 TH38 TH39 TH40 TH41 TH42 TH43 TH44 TH45 TH46 TH47 TH48 TH49 TH50 TH51 TH52 TH53 TH54 TH55 TH56 TH57 TH58 TH59 TH60 TH61 TH62 THB0 THB1 THB2 THB3 THB4 THB5 THB6 THB7 THB8 THB9 THB10 THB11 THB12 THB13 THB14 THB15 THB16 THB17 THB18 THB19 THB20 THB21 THB22 THB23 THB24 THB25 THB26 THB27 THB28 THB29 THB30 THB31 THB32 THB33 THB34 THB35 THB36 THB37 THB38 THB39 THB40 THB41 THB42 THB43 THB44 THB45 THB46 THB47 THB48 THB49 THB50 THB51 THB52 THB53 THB54 THB55 THB56 THB57 THB58 THB59 THB60 THB61 THB62 dac_logic
XIEN_0 ENB EN VSS VSS nfet_03v3 w=1.0u l=0.28u
XIEP_0 ENB EN VDD VDD pfet_03v3 w=2.0u l=0.28u
XBSW_0 IBIAS EN ATB_BIAS VSS nfet_03v3 w=4u l=0.5u
XBD_0 ATB_BIAS ATB_BIAS VSS VSS nfet_03v3 w=4u l=2u
XBPD_0 ATB_BIAS ENB VSS VSS nfet_03v3 w=1u l=0.5u
XKI1NA_0 Ky2 CLK KI1_m VSS nfet_03v3 w=4u l=0.28u
XKI1NB_0 KI1_m EN VSS VSS nfet_03v3 w=4u l=0.28u
XKI1PA_0 Ky2 CLK VDD VDD pfet_03v3 w=4u l=0.28u
XKI1PB_0 Ky2 EN VDD VDD pfet_03v3 w=4u l=0.28u
XKGNA_0 Kz Ky2 KG_m VSS nfet_03v3 w=2.0u l=0.28u
XKGNB_0 KG_m EN VSS VSS nfet_03v3 w=2.0u l=0.28u
XKGPA_0 Kz Ky2 VDD VDD pfet_03v3 w=2.0u l=0.28u
XKGPB_0 Kz EN VDD VDD pfet_03v3 w=2.0u l=0.28u
XKI3N_0 CK Kz VSS VSS nfet_03v3 w=2u l=0.28u
XKI3P_0 CK Kz VDD VDD pfet_03v3 w=4u l=0.28u
XSA0_0 ONI TH0 CS0 VSS nfet_03v3 w=1u l=0.28u
XSB0_0 OPI THB0 CS0 VSS nfet_03v3 w=1u l=0.28u
XSA1_0 ONI TH1 CS1 VSS nfet_03v3 w=1u l=0.28u
XSB1_0 OPI THB1 CS1 VSS nfet_03v3 w=1u l=0.28u
XSA2_0 ONI TH2 CS2 VSS nfet_03v3 w=1u l=0.28u
XSB2_0 OPI THB2 CS2 VSS nfet_03v3 w=1u l=0.28u
XSA3_0 ONI TH3 CS3 VSS nfet_03v3 w=1u l=0.28u
XSB3_0 OPI THB3 CS3 VSS nfet_03v3 w=1u l=0.28u
XSA4_0 ONI TH4 CS4 VSS nfet_03v3 w=1u l=0.28u
XSB4_0 OPI THB4 CS4 VSS nfet_03v3 w=1u l=0.28u
XSA5_0 ONI TH5 CS5 VSS nfet_03v3 w=1u l=0.28u
XSB5_0 OPI THB5 CS5 VSS nfet_03v3 w=1u l=0.28u
XSA6_0 ONI TH6 CS6 VSS nfet_03v3 w=1u l=0.28u
XSB6_0 OPI THB6 CS6 VSS nfet_03v3 w=1u l=0.28u
XSA7_0 ONI TH7 CS7 VSS nfet_03v3 w=1u l=0.28u
XSB7_0 OPI THB7 CS7 VSS nfet_03v3 w=1u l=0.28u
XSA8_0 ONI TH8 CS8 VSS nfet_03v3 w=1u l=0.28u
XSB8_0 OPI THB8 CS8 VSS nfet_03v3 w=1u l=0.28u
XSA9_0 ONI TH9 CS9 VSS nfet_03v3 w=1u l=0.28u
XSB9_0 OPI THB9 CS9 VSS nfet_03v3 w=1u l=0.28u
XSA10_0 ONI TH10 CS10 VSS nfet_03v3 w=1u l=0.28u
XSB10_0 OPI THB10 CS10 VSS nfet_03v3 w=1u l=0.28u
XSA11_0 ONI TH11 CS11 VSS nfet_03v3 w=1u l=0.28u
XSB11_0 OPI THB11 CS11 VSS nfet_03v3 w=1u l=0.28u
XSA12_0 ONI TH12 CS12 VSS nfet_03v3 w=1u l=0.28u
XSB12_0 OPI THB12 CS12 VSS nfet_03v3 w=1u l=0.28u
XSA13_0 ONI TH13 CS13 VSS nfet_03v3 w=1u l=0.28u
XSB13_0 OPI THB13 CS13 VSS nfet_03v3 w=1u l=0.28u
XSA14_0 ONI TH14 CS14 VSS nfet_03v3 w=1u l=0.28u
XSB14_0 OPI THB14 CS14 VSS nfet_03v3 w=1u l=0.28u
XSA15_0 ONI TH15 CS15 VSS nfet_03v3 w=1u l=0.28u
XSB15_0 OPI THB15 CS15 VSS nfet_03v3 w=1u l=0.28u
XSA16_0 ONI TH16 CS16 VSS nfet_03v3 w=1u l=0.28u
XSB16_0 OPI THB16 CS16 VSS nfet_03v3 w=1u l=0.28u
XSA17_0 ONI TH17 CS17 VSS nfet_03v3 w=1u l=0.28u
XSB17_0 OPI THB17 CS17 VSS nfet_03v3 w=1u l=0.28u
XSA18_0 ONI TH18 CS18 VSS nfet_03v3 w=1u l=0.28u
XSB18_0 OPI THB18 CS18 VSS nfet_03v3 w=1u l=0.28u
XSA19_0 ONI TH19 CS19 VSS nfet_03v3 w=1u l=0.28u
XSB19_0 OPI THB19 CS19 VSS nfet_03v3 w=1u l=0.28u
XSA20_0 ONI TH20 CS20 VSS nfet_03v3 w=1u l=0.28u
XSB20_0 OPI THB20 CS20 VSS nfet_03v3 w=1u l=0.28u
XSA21_0 ONI TH21 CS21 VSS nfet_03v3 w=1u l=0.28u
XSB21_0 OPI THB21 CS21 VSS nfet_03v3 w=1u l=0.28u
XSA22_0 ONI TH22 CS22 VSS nfet_03v3 w=1u l=0.28u
XSB22_0 OPI THB22 CS22 VSS nfet_03v3 w=1u l=0.28u
XSA23_0 ONI TH23 CS23 VSS nfet_03v3 w=1u l=0.28u
XSB23_0 OPI THB23 CS23 VSS nfet_03v3 w=1u l=0.28u
XSA24_0 ONI TH24 CS24 VSS nfet_03v3 w=1u l=0.28u
XSB24_0 OPI THB24 CS24 VSS nfet_03v3 w=1u l=0.28u
XSA25_0 ONI TH25 CS25 VSS nfet_03v3 w=1u l=0.28u
XSB25_0 OPI THB25 CS25 VSS nfet_03v3 w=1u l=0.28u
XSA26_0 ONI TH26 CS26 VSS nfet_03v3 w=1u l=0.28u
XSB26_0 OPI THB26 CS26 VSS nfet_03v3 w=1u l=0.28u
XSA27_0 ONI TH27 CS27 VSS nfet_03v3 w=1u l=0.28u
XSB27_0 OPI THB27 CS27 VSS nfet_03v3 w=1u l=0.28u
XSA28_0 ONI TH28 CS28 VSS nfet_03v3 w=1u l=0.28u
XSB28_0 OPI THB28 CS28 VSS nfet_03v3 w=1u l=0.28u
XSA29_0 ONI TH29 CS29 VSS nfet_03v3 w=1u l=0.28u
XSB29_0 OPI THB29 CS29 VSS nfet_03v3 w=1u l=0.28u
XSA30_0 ONI TH30 CS30 VSS nfet_03v3 w=1u l=0.28u
XSB30_0 OPI THB30 CS30 VSS nfet_03v3 w=1u l=0.28u
XSA31_0 ONI TH31 CS31 VSS nfet_03v3 w=1u l=0.28u
XSB31_0 OPI THB31 CS31 VSS nfet_03v3 w=1u l=0.28u
XSA32_0 ONI TH32 CS32 VSS nfet_03v3 w=1u l=0.28u
XSB32_0 OPI THB32 CS32 VSS nfet_03v3 w=1u l=0.28u
XSA33_0 ONI TH33 CS33 VSS nfet_03v3 w=1u l=0.28u
XSB33_0 OPI THB33 CS33 VSS nfet_03v3 w=1u l=0.28u
XSA34_0 ONI TH34 CS34 VSS nfet_03v3 w=1u l=0.28u
XSB34_0 OPI THB34 CS34 VSS nfet_03v3 w=1u l=0.28u
XSA35_0 ONI TH35 CS35 VSS nfet_03v3 w=1u l=0.28u
XSB35_0 OPI THB35 CS35 VSS nfet_03v3 w=1u l=0.28u
XSA36_0 ONI TH36 CS36 VSS nfet_03v3 w=1u l=0.28u
XSB36_0 OPI THB36 CS36 VSS nfet_03v3 w=1u l=0.28u
XSA37_0 ONI TH37 CS37 VSS nfet_03v3 w=1u l=0.28u
XSB37_0 OPI THB37 CS37 VSS nfet_03v3 w=1u l=0.28u
XSA38_0 ONI TH38 CS38 VSS nfet_03v3 w=1u l=0.28u
XSB38_0 OPI THB38 CS38 VSS nfet_03v3 w=1u l=0.28u
XSA39_0 ONI TH39 CS39 VSS nfet_03v3 w=1u l=0.28u
XSB39_0 OPI THB39 CS39 VSS nfet_03v3 w=1u l=0.28u
XSA40_0 ONI TH40 CS40 VSS nfet_03v3 w=1u l=0.28u
XSB40_0 OPI THB40 CS40 VSS nfet_03v3 w=1u l=0.28u
XSA41_0 ONI TH41 CS41 VSS nfet_03v3 w=1u l=0.28u
XSB41_0 OPI THB41 CS41 VSS nfet_03v3 w=1u l=0.28u
XSA42_0 ONI TH42 CS42 VSS nfet_03v3 w=1u l=0.28u
XSB42_0 OPI THB42 CS42 VSS nfet_03v3 w=1u l=0.28u
XSA43_0 ONI TH43 CS43 VSS nfet_03v3 w=1u l=0.28u
XSB43_0 OPI THB43 CS43 VSS nfet_03v3 w=1u l=0.28u
XSA44_0 ONI TH44 CS44 VSS nfet_03v3 w=1u l=0.28u
XSB44_0 OPI THB44 CS44 VSS nfet_03v3 w=1u l=0.28u
XSA45_0 ONI TH45 CS45 VSS nfet_03v3 w=1u l=0.28u
XSB45_0 OPI THB45 CS45 VSS nfet_03v3 w=1u l=0.28u
XSA46_0 ONI TH46 CS46 VSS nfet_03v3 w=1u l=0.28u
XSB46_0 OPI THB46 CS46 VSS nfet_03v3 w=1u l=0.28u
XSA47_0 ONI TH47 CS47 VSS nfet_03v3 w=1u l=0.28u
XSB47_0 OPI THB47 CS47 VSS nfet_03v3 w=1u l=0.28u
XSA48_0 ONI TH48 CS48 VSS nfet_03v3 w=1u l=0.28u
XSB48_0 OPI THB48 CS48 VSS nfet_03v3 w=1u l=0.28u
XSA49_0 ONI TH49 CS49 VSS nfet_03v3 w=1u l=0.28u
XSB49_0 OPI THB49 CS49 VSS nfet_03v3 w=1u l=0.28u
XSA50_0 ONI TH50 CS50 VSS nfet_03v3 w=1u l=0.28u
XSB50_0 OPI THB50 CS50 VSS nfet_03v3 w=1u l=0.28u
XSA51_0 ONI TH51 CS51 VSS nfet_03v3 w=1u l=0.28u
XSB51_0 OPI THB51 CS51 VSS nfet_03v3 w=1u l=0.28u
XSA52_0 ONI TH52 CS52 VSS nfet_03v3 w=1u l=0.28u
XSB52_0 OPI THB52 CS52 VSS nfet_03v3 w=1u l=0.28u
XSA53_0 ONI TH53 CS53 VSS nfet_03v3 w=1u l=0.28u
XSB53_0 OPI THB53 CS53 VSS nfet_03v3 w=1u l=0.28u
XSA54_0 ONI TH54 CS54 VSS nfet_03v3 w=1u l=0.28u
XSB54_0 OPI THB54 CS54 VSS nfet_03v3 w=1u l=0.28u
XSA55_0 ONI TH55 CS55 VSS nfet_03v3 w=1u l=0.28u
XSB55_0 OPI THB55 CS55 VSS nfet_03v3 w=1u l=0.28u
XSA56_0 ONI TH56 CS56 VSS nfet_03v3 w=1u l=0.28u
XSB56_0 OPI THB56 CS56 VSS nfet_03v3 w=1u l=0.28u
XSA57_0 ONI TH57 CS57 VSS nfet_03v3 w=1u l=0.28u
XSB57_0 OPI THB57 CS57 VSS nfet_03v3 w=1u l=0.28u
XSA58_0 ONI TH58 CS58 VSS nfet_03v3 w=1u l=0.28u
XSB58_0 OPI THB58 CS58 VSS nfet_03v3 w=1u l=0.28u
XSA59_0 ONI TH59 CS59 VSS nfet_03v3 w=1u l=0.28u
XSB59_0 OPI THB59 CS59 VSS nfet_03v3 w=1u l=0.28u
XSA60_0 ONI TH60 CS60 VSS nfet_03v3 w=1u l=0.28u
XSB60_0 OPI THB60 CS60 VSS nfet_03v3 w=1u l=0.28u
XSA61_0 ONI TH61 CS61 VSS nfet_03v3 w=1u l=0.28u
XSB61_0 OPI THB61 CS61 VSS nfet_03v3 w=1u l=0.28u
XSA62_0 ONI TH62 CS62 VSS nfet_03v3 w=1u l=0.28u
XSB62_0 OPI THB62 CS62 VSS nfet_03v3 w=1u l=0.28u
XSA63_0 ONI BN0 CS63 VSS nfet_03v3 w=1u l=0.28u
XSB63_0 OPI BNB0 CS63 VSS nfet_03v3 w=1u l=0.28u
XSA64_0 ONI BN1 CS64 VSS nfet_03v3 w=1u l=0.28u
XSB64_0 OPI BNB1 CS64 VSS nfet_03v3 w=1u l=0.28u
XSA65_0 ONI BN2 CS65 VSS nfet_03v3 w=1u l=0.28u
XSB65_0 OPI BNB2 CS65 VSS nfet_03v3 w=1u l=0.28u
XSA66_0 ONI BN3 CS66 VSS nfet_03v3 w=1u l=0.28u
XSB66_0 OPI BNB3 CS66 VSS nfet_03v3 w=1u l=0.28u
XCS0_0 CD0 ATB_BIAS VSS VSS nfet_03v3 w=6.256u l=2u
XCS1_0 CD1 ATB_BIAS VSS VSS nfet_03v3 w=6.256u l=2u
XCS2_0 CD2 ATB_BIAS VSS VSS nfet_03v3 w=6.256u l=2u
XCS3_0 CD3 ATB_BIAS VSS VSS nfet_03v3 w=6.256u l=2u
XCS4_0 CD4 ATB_BIAS VSS VSS nfet_03v3 w=6.256u l=2u
XCS5_0 CD5 ATB_BIAS VSS VSS nfet_03v3 w=6.256u l=2u
XCS6_0 CD6 ATB_BIAS VSS VSS nfet_03v3 w=6.256u l=2u
XCS7_0 CD7 ATB_BIAS VSS VSS nfet_03v3 w=6.256u l=2u
XCS8_0 CD8 ATB_BIAS VSS VSS nfet_03v3 w=6.256u l=2u
XCS9_0 CD9 ATB_BIAS VSS VSS nfet_03v3 w=6.256u l=2u
XCS10_0 CD10 ATB_BIAS VSS VSS nfet_03v3 w=6.256u l=2u
XCS11_0 CD11 ATB_BIAS VSS VSS nfet_03v3 w=6.256u l=2u
XCS12_0 CD12 ATB_BIAS VSS VSS nfet_03v3 w=6.256u l=2u
XCS13_0 CD13 ATB_BIAS VSS VSS nfet_03v3 w=6.256u l=2u
XCS14_0 CD14 ATB_BIAS VSS VSS nfet_03v3 w=6.256u l=2u
XCS15_0 CD15 ATB_BIAS VSS VSS nfet_03v3 w=6.256u l=2u
XCS16_0 CD16 ATB_BIAS VSS VSS nfet_03v3 w=6.256u l=2u
XCS17_0 CD17 ATB_BIAS VSS VSS nfet_03v3 w=6.256u l=2u
XCS18_0 CD18 ATB_BIAS VSS VSS nfet_03v3 w=6.256u l=2u
XCS19_0 CD19 ATB_BIAS VSS VSS nfet_03v3 w=6.256u l=2u
XCS20_0 CD20 ATB_BIAS VSS VSS nfet_03v3 w=6.256u l=2u
XCS21_0 CD21 ATB_BIAS VSS VSS nfet_03v3 w=6.256u l=2u
XCS22_0 CD22 ATB_BIAS VSS VSS nfet_03v3 w=6.256u l=2u
XCS23_0 CD23 ATB_BIAS VSS VSS nfet_03v3 w=6.256u l=2u
XCS24_0 CD24 ATB_BIAS VSS VSS nfet_03v3 w=6.256u l=2u
XCS25_0 CD25 ATB_BIAS VSS VSS nfet_03v3 w=6.256u l=2u
XCS26_0 CD26 ATB_BIAS VSS VSS nfet_03v3 w=6.256u l=2u
XCS27_0 CD27 ATB_BIAS VSS VSS nfet_03v3 w=6.256u l=2u
XCS28_0 CD28 ATB_BIAS VSS VSS nfet_03v3 w=6.256u l=2u
XCS29_0 CD29 ATB_BIAS VSS VSS nfet_03v3 w=6.256u l=2u
XCS30_0 CD30 ATB_BIAS VSS VSS nfet_03v3 w=6.256u l=2u
XCS31_0 CD31 ATB_BIAS VSS VSS nfet_03v3 w=6.256u l=2u
XCS32_0 CD32 ATB_BIAS VSS VSS nfet_03v3 w=6.256u l=2u
XCS33_0 CD33 ATB_BIAS VSS VSS nfet_03v3 w=6.256u l=2u
XCS34_0 CD34 ATB_BIAS VSS VSS nfet_03v3 w=6.256u l=2u
XCS35_0 CD35 ATB_BIAS VSS VSS nfet_03v3 w=6.256u l=2u
XCS36_0 CD36 ATB_BIAS VSS VSS nfet_03v3 w=6.256u l=2u
XCS37_0 CD37 ATB_BIAS VSS VSS nfet_03v3 w=6.256u l=2u
XCS38_0 CD38 ATB_BIAS VSS VSS nfet_03v3 w=6.256u l=2u
XCS39_0 CD39 ATB_BIAS VSS VSS nfet_03v3 w=6.256u l=2u
XCS40_0 CD40 ATB_BIAS VSS VSS nfet_03v3 w=6.256u l=2u
XCS41_0 CD41 ATB_BIAS VSS VSS nfet_03v3 w=6.256u l=2u
XCS42_0 CD42 ATB_BIAS VSS VSS nfet_03v3 w=6.256u l=2u
XCS43_0 CD43 ATB_BIAS VSS VSS nfet_03v3 w=6.256u l=2u
XCS44_0 CD44 ATB_BIAS VSS VSS nfet_03v3 w=6.256u l=2u
XCS45_0 CD45 ATB_BIAS VSS VSS nfet_03v3 w=6.256u l=2u
XCS46_0 CD46 ATB_BIAS VSS VSS nfet_03v3 w=6.256u l=2u
XCS47_0 CD47 ATB_BIAS VSS VSS nfet_03v3 w=6.256u l=2u
XCS48_0 CD48 ATB_BIAS VSS VSS nfet_03v3 w=6.256u l=2u
XCS49_0 CD49 ATB_BIAS VSS VSS nfet_03v3 w=6.256u l=2u
XCS50_0 CD50 ATB_BIAS VSS VSS nfet_03v3 w=6.256u l=2u
XCS51_0 CD51 ATB_BIAS VSS VSS nfet_03v3 w=6.256u l=2u
XCS52_0 CD52 ATB_BIAS VSS VSS nfet_03v3 w=6.256u l=2u
XCS53_0 CD53 ATB_BIAS VSS VSS nfet_03v3 w=6.256u l=2u
XCS54_0 CD54 ATB_BIAS VSS VSS nfet_03v3 w=6.256u l=2u
XCS55_0 CD55 ATB_BIAS VSS VSS nfet_03v3 w=6.256u l=2u
XCS56_0 CD56 ATB_BIAS VSS VSS nfet_03v3 w=6.256u l=2u
XCS57_0 CD57 ATB_BIAS VSS VSS nfet_03v3 w=6.256u l=2u
XCS58_0 CD58 ATB_BIAS VSS VSS nfet_03v3 w=6.256u l=2u
XCS59_0 CD59 ATB_BIAS VSS VSS nfet_03v3 w=6.256u l=2u
XCS60_0 CD60 ATB_BIAS VSS VSS nfet_03v3 w=6.256u l=2u
XCS61_0 CD61 ATB_BIAS VSS VSS nfet_03v3 w=6.256u l=2u
XCS62_0 CD62 ATB_BIAS VSS VSS nfet_03v3 w=6.256u l=2u
XCS63_0 CD63 ATB_BIAS VSS VSS nfet_03v3 w=0.391u l=2u
XCS64_0 CD64 ATB_BIAS VSS VSS nfet_03v3 w=0.782u l=2u
XCS65_0 CD65 ATB_BIAS VSS VSS nfet_03v3 w=1.564u l=2u
XCS66_0 CD66 ATB_BIAS VSS VSS nfet_03v3 w=3.128u l=2u
XCC0_0 CS0 VCASC CD0 VSS nfet_03v3 w=12.512u l=0.5u
XCC1_0 CS1 VCASC CD1 VSS nfet_03v3 w=12.512u l=0.5u
XCC2_0 CS2 VCASC CD2 VSS nfet_03v3 w=12.512u l=0.5u
XCC3_0 CS3 VCASC CD3 VSS nfet_03v3 w=12.512u l=0.5u
XCC4_0 CS4 VCASC CD4 VSS nfet_03v3 w=12.512u l=0.5u
XCC5_0 CS5 VCASC CD5 VSS nfet_03v3 w=12.512u l=0.5u
XCC6_0 CS6 VCASC CD6 VSS nfet_03v3 w=12.512u l=0.5u
XCC7_0 CS7 VCASC CD7 VSS nfet_03v3 w=12.512u l=0.5u
XCC8_0 CS8 VCASC CD8 VSS nfet_03v3 w=12.512u l=0.5u
XCC9_0 CS9 VCASC CD9 VSS nfet_03v3 w=12.512u l=0.5u
XCC10_0 CS10 VCASC CD10 VSS nfet_03v3 w=12.512u l=0.5u
XCC11_0 CS11 VCASC CD11 VSS nfet_03v3 w=12.512u l=0.5u
XCC12_0 CS12 VCASC CD12 VSS nfet_03v3 w=12.512u l=0.5u
XCC13_0 CS13 VCASC CD13 VSS nfet_03v3 w=12.512u l=0.5u
XCC14_0 CS14 VCASC CD14 VSS nfet_03v3 w=12.512u l=0.5u
XCC15_0 CS15 VCASC CD15 VSS nfet_03v3 w=12.512u l=0.5u
XCC16_0 CS16 VCASC CD16 VSS nfet_03v3 w=12.512u l=0.5u
XCC17_0 CS17 VCASC CD17 VSS nfet_03v3 w=12.512u l=0.5u
XCC18_0 CS18 VCASC CD18 VSS nfet_03v3 w=12.512u l=0.5u
XCC19_0 CS19 VCASC CD19 VSS nfet_03v3 w=12.512u l=0.5u
XCC20_0 CS20 VCASC CD20 VSS nfet_03v3 w=12.512u l=0.5u
XCC21_0 CS21 VCASC CD21 VSS nfet_03v3 w=12.512u l=0.5u
XCC22_0 CS22 VCASC CD22 VSS nfet_03v3 w=12.512u l=0.5u
XCC23_0 CS23 VCASC CD23 VSS nfet_03v3 w=12.512u l=0.5u
XCC24_0 CS24 VCASC CD24 VSS nfet_03v3 w=12.512u l=0.5u
XCC25_0 CS25 VCASC CD25 VSS nfet_03v3 w=12.512u l=0.5u
XCC26_0 CS26 VCASC CD26 VSS nfet_03v3 w=12.512u l=0.5u
XCC27_0 CS27 VCASC CD27 VSS nfet_03v3 w=12.512u l=0.5u
XCC28_0 CS28 VCASC CD28 VSS nfet_03v3 w=12.512u l=0.5u
XCC29_0 CS29 VCASC CD29 VSS nfet_03v3 w=12.512u l=0.5u
XCC30_0 CS30 VCASC CD30 VSS nfet_03v3 w=12.512u l=0.5u
XCC31_0 CS31 VCASC CD31 VSS nfet_03v3 w=12.512u l=0.5u
XCC32_0 CS32 VCASC CD32 VSS nfet_03v3 w=12.512u l=0.5u
XCC33_0 CS33 VCASC CD33 VSS nfet_03v3 w=12.512u l=0.5u
XCC34_0 CS34 VCASC CD34 VSS nfet_03v3 w=12.512u l=0.5u
XCC35_0 CS35 VCASC CD35 VSS nfet_03v3 w=12.512u l=0.5u
XCC36_0 CS36 VCASC CD36 VSS nfet_03v3 w=12.512u l=0.5u
XCC37_0 CS37 VCASC CD37 VSS nfet_03v3 w=12.512u l=0.5u
XCC38_0 CS38 VCASC CD38 VSS nfet_03v3 w=12.512u l=0.5u
XCC39_0 CS39 VCASC CD39 VSS nfet_03v3 w=12.512u l=0.5u
XCC40_0 CS40 VCASC CD40 VSS nfet_03v3 w=12.512u l=0.5u
XCC41_0 CS41 VCASC CD41 VSS nfet_03v3 w=12.512u l=0.5u
XCC42_0 CS42 VCASC CD42 VSS nfet_03v3 w=12.512u l=0.5u
XCC43_0 CS43 VCASC CD43 VSS nfet_03v3 w=12.512u l=0.5u
XCC44_0 CS44 VCASC CD44 VSS nfet_03v3 w=12.512u l=0.5u
XCC45_0 CS45 VCASC CD45 VSS nfet_03v3 w=12.512u l=0.5u
XCC46_0 CS46 VCASC CD46 VSS nfet_03v3 w=12.512u l=0.5u
XCC47_0 CS47 VCASC CD47 VSS nfet_03v3 w=12.512u l=0.5u
XCC48_0 CS48 VCASC CD48 VSS nfet_03v3 w=12.512u l=0.5u
XCC49_0 CS49 VCASC CD49 VSS nfet_03v3 w=12.512u l=0.5u
XCC50_0 CS50 VCASC CD50 VSS nfet_03v3 w=12.512u l=0.5u
XCC51_0 CS51 VCASC CD51 VSS nfet_03v3 w=12.512u l=0.5u
XCC52_0 CS52 VCASC CD52 VSS nfet_03v3 w=12.512u l=0.5u
XCC53_0 CS53 VCASC CD53 VSS nfet_03v3 w=12.512u l=0.5u
XCC54_0 CS54 VCASC CD54 VSS nfet_03v3 w=12.512u l=0.5u
XCC55_0 CS55 VCASC CD55 VSS nfet_03v3 w=12.512u l=0.5u
XCC56_0 CS56 VCASC CD56 VSS nfet_03v3 w=12.512u l=0.5u
XCC57_0 CS57 VCASC CD57 VSS nfet_03v3 w=12.512u l=0.5u
XCC58_0 CS58 VCASC CD58 VSS nfet_03v3 w=12.512u l=0.5u
XCC59_0 CS59 VCASC CD59 VSS nfet_03v3 w=12.512u l=0.5u
XCC60_0 CS60 VCASC CD60 VSS nfet_03v3 w=12.512u l=0.5u
XCC61_0 CS61 VCASC CD61 VSS nfet_03v3 w=12.512u l=0.5u
XCC62_0 CS62 VCASC CD62 VSS nfet_03v3 w=12.512u l=0.5u
XCC63_0 CS63 VCASC CD63 VSS nfet_03v3 w=0.782u l=0.5u
XCC64_0 CS64 VCASC CD64 VSS nfet_03v3 w=1.564u l=0.5u
XCC65_0 CS65 VCASC CD65 VSS nfet_03v3 w=3.128u l=0.5u
XCC66_0 CS66 VCASC CD66 VSS nfet_03v3 w=6.256u l=0.5u
XKBN_0 KPG ATB_BIAS VSS VSS nfet_03v3 w=4u l=2u
XKBP1_0 KPG KPG VDD VDD pfet_03v3 w=4u l=1u
XKBP2_0 VCASC KPG VDD VDD pfet_03v3 w=4u l=1u
XKBD_0 VCASC VCASC VSS VSS nfet_03v3 w=1u l=3u
XKPD_0 VCASC ENB VSS VSS nfet_03v3 w=1u l=0.5u
XCDAB_0 ATB_BIAS VSS cap_mim_2f0_m4m5_noshield c_width=22u c_length=22u
XCDVC_0 VCASC VSS cap_mim_2f0_m4m5_noshield c_width=22u c_length=22u
XRCP_0 OPI CMS VSS ppolyf_u_1k r_width=1u r_length=20u
XRCN_0 ONI CMS VSS ppolyf_u_1k r_width=1u r_length=20u
XRDA_0 VDD CMRA VSS ppolyf_u_1k r_width=1u r_length=25u
XRDA2_0 CMRA CMR VSS ppolyf_u_1k r_width=1u r_length=25u
XRDB_0 CMR CMRB VSS ppolyf_u_1k r_width=1u r_length=25u
XRDB2_0 CMRB CMRF VSS ppolyf_u_1k r_width=1u r_length=25u
XMDF_0 CMRF EN VSS VSS nfet_03v3 w=4u l=0.28u
XOTT_0 OTS ATB_BIAS VSS VSS nfet_03v3 w=16u l=2u
XOT1_0 OTD CMS OTS VSS nfet_03v3 w=4u l=1u
XOT2_0 HG CMR OTS VSS nfet_03v3 w=4u l=1u
XOT3_0 OTD OTD VDD VDD pfet_03v3 w=4u l=1u
XOT4_0 HG OTD VDD VDD pfet_03v3 w=4u l=1u
XOTU_0 HG LOAD_EN VDD VDD pfet_03v3 w=2u l=0.28u
XOTC_0 HG T cap_mim_2f0_m4m5_noshield c_width=22u c_length=22u
XILEN_0 LOAD_EN LOAD_ENB VSS VSS nfet_03v3 w=1.0u l=0.28u
XILEP_0 LOAD_EN LOAD_ENB VDD VDD pfet_03v3 w=2.0u l=0.28u
XMHDR_0 T HG VDD VDD pfet_03v3 w=10u l=0.5u
XMHDR_1 T HG VDD VDD pfet_03v3 w=10u l=0.5u
XMHDR_2 T HG VDD VDD pfet_03v3 w=10u l=0.5u
XMHDR_3 T HG VDD VDD pfet_03v3 w=10u l=0.5u
XRLP_0 T OPI VSS ppolyf_u_1k r_width=4u r_length=4u
XRLN_0 T ONI VSS ppolyf_u_1k r_width=4u r_length=4u
XMOP_0 OPI OUT_EN OUTP VSS nfet_03v3 w=10u l=0.28u
XMOP_1 OPI OUT_EN OUTP VSS nfet_03v3 w=10u l=0.28u
XMON_0 ONI OUT_EN OUTN VSS nfet_03v3 w=10u l=0.28u
XMON_1 ONI OUT_EN OUTN VSS nfet_03v3 w=10u l=0.28u
DANT0 VSS CODE0 diode_nd2ps_03v3 area=0.6889p pj=3.32u
DANT1 VSS CODE1 diode_nd2ps_03v3 area=0.9025p pj=3.8u
DANT2 VSS CODE2 diode_nd2ps_03v3 area=1.103p pj=4.2u
DANT3 VSS CODE3 diode_nd2ps_03v3 area=1.3p pj=4.56u
DANT4 VSS CODE4 diode_nd2ps_03v3 area=1.513p pj=4.92u
DANT5 VSS CODE5 diode_nd2ps_03v3 area=1.716p pj=5.24u
DANT6 VSS CODE6 diode_nd2ps_03v3 area=1.904p pj=5.52u
DANT7 VSS CODE7 diode_nd2ps_03v3 area=2.103p pj=5.8u
DANT8 VSS CODE8 diode_nd2ps_03v3 area=2.31p pj=6.08u
DANT9 VSS CODE9 diode_nd2ps_03v3 area=2.341p pj=6.12u
DANT10 VSS HOLD_ZERO diode_nd2ps_03v3 area=0.3721p pj=2.44u
DANT11 VSS EN diode_nd2ps_03v3 area=12.04p pj=13.88u
DANT12 VSS HOLD_ZERO diode_nd2ps_03v3 area=12.04p pj=13.88u
DANT13 VSS CODE0 diode_nd2ps_03v3 area=12.04p pj=13.88u
DANT14 VSS CODE1 diode_nd2ps_03v3 area=12.04p pj=13.88u
DANT15 VSS CODE2 diode_nd2ps_03v3 area=12.04p pj=13.88u
DANT16 VSS CODE3 diode_nd2ps_03v3 area=12.04p pj=13.88u
DANT17 VSS CODE4 diode_nd2ps_03v3 area=12.04p pj=13.88u
DANT18 VSS CODE5 diode_nd2ps_03v3 area=12.04p pj=13.88u
DANT19 VSS CODE6 diode_nd2ps_03v3 area=12.04p pj=13.88u
DANT20 VSS CODE7 diode_nd2ps_03v3 area=12.04p pj=13.88u
DANT21 VSS CODE8 diode_nd2ps_03v3 area=12.04p pj=13.88u
DANT22 VSS CODE9 diode_nd2ps_03v3 area=12.04p pj=13.88u
.ends
