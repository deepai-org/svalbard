* NGSPICE file created from pt_refbuf.ext - technology: gf180mcuD

.subckt pt_refbuf VDD VSS VREF0 VREF IBIAS EN OVR READY
X0 VREF VSS cap_mim_2f0_m4m5_noshield c_width=70.7u c_length=70.7u
X1 XA XA VDDA VDD pfet_03v3 ad=1.76p pd=8.88u as=1.76p ps=8.88u w=4u l=2u
X2 NB ACTB VSS VSS nfet_03v3 ad=0.44p pd=2.88u as=0.44p ps=2.88u w=1u l=0.5u
X3 NA_m OVRB VSS VSS nfet_03v3 ad=0.88p pd=4.88u as=0.88p ps=4.88u w=2u l=0.28u
X4 NR_m YB VDD VDD pfet_03v3 ad=1.76p pd=8.88u as=1.76p ps=8.88u w=4u l=0.28u
X5 Y ACTB VSS VSS nfet_03v3 ad=3.96p pd=19.76u as=99.43999p ps=0.47136m w=1u l=0.5u
X6 TN NB VSS VSS nfet_03v3 ad=3.52p pd=16.88u as=3.52p ps=16.88u w=8u l=2u
X7 XA VREF0 TN VSS nfet_03v3 ad=4.4p pd=20.88u as=4.4p ps=20.88u w=10u l=1u
X8 ACTB EN VDD VDD pfet_03v3 ad=0.88p pd=4.88u as=0.88p ps=4.88u w=2u l=0.28u
X9 Y YA VDDA VDD pfet_03v3 ad=1.76p pd=8.88u as=1.76p ps=8.88u w=4u l=1u
X10 OVRB OVR VDD VDD pfet_03v3 ad=0.88p pd=4.88u as=9.68p ps=50.16u w=2u l=0.28u
X11 READY YB VSS VSS nfet_03v3 ad=0.44p pd=2.88u as=0.44p ps=2.88u w=1u l=0.28u
X12 VREF VSS cap_mim_2f0_m4m5_noshield c_width=70.7u c_length=70.7u
X13 YA VREF TC VSS nfet_03v3 ad=3.52p pd=16.88u as=3.52p ps=16.88u w=8u l=1u
X14 YA VREF TC VSS nfet_03v3 ad=7.04p pd=33.76u as=12.32p ps=59.52u w=8u l=1u
X15 VREF VSS cap_mim_2f0_m4m5_noshield c_width=70.7u c_length=70.7u
X16 OVRB OVR VSS VSS nfet_03v3 ad=0.44p pd=2.88u as=0 ps=0 w=1u l=0.28u
X17 VREF VSS cap_mim_2f0_m4m5_noshield c_width=70.7u c_length=70.7u
X18 X XA VDDA VDD pfet_03v3 ad=1.76p pd=8.88u as=10.56p ps=52.4u w=4u l=2u
X19 VREF VSS cap_mim_2f0_m4m5_noshield c_width=70.7u c_length=70.7u
X20 READY ACTB NR_m VDD pfet_03v3 ad=1.76p pd=8.88u as=3.52p ps=17.76u w=4u l=0.28u
X21 VREF VSS cap_mim_2f0_m4m5_noshield c_width=70.7u c_length=70.7u
X22 X VREF TN VSS nfet_03v3 ad=4.84p pd=23.76u as=12.32p ps=58.64u w=10u l=1u
X23 ACT ACTB VDD VDD pfet_03v3 ad=0.88p pd=4.88u as=0 ps=0 w=2u l=0.28u
X24 ACTB EN NA_m VSS nfet_03v3 ad=0.88p pd=4.88u as=1.76p ps=9.76u w=2u l=0.28u
X25 VREF NB VSS VSS nfet_03v3 ad=8.8p pd=40.88u as=8.8p ps=40.88u w=20u l=2u
X26 VDDA ACTB VDD VDD pfet_03v3 ad=3.52p pd=16.88u as=3.52p ps=16.88u w=8u l=0.28u
X27 VREF NB VSS VSS nfet_03v3 ad=0.1056n pd=0.49232m as=0 ps=0 w=20u l=2u
X28 VREF NB VSS VSS nfet_03v3 ad=0 pd=0 as=0 ps=0 w=20u l=2u
X29 VDD X VREF VSS nfet_03v3 ad=4.4p pd=20.88u as=4.4p ps=20.88u w=10u l=0.5u
X30 ACT ACTB VSS VSS nfet_03v3 ad=0.44p pd=2.88u as=0 ps=0 w=1u l=0.28u
X31 VREF NB VSS VSS nfet_03v3 ad=0 pd=0 as=0 ps=0 w=20u l=2u
X32 IBIAS ACT NB VSS nfet_03v3 ad=1.76p pd=8.88u as=1.76p ps=8.88u w=4u l=0.5u
X33 VDD X VREF VSS nfet_03v3 ad=92.3072p pd=0.49856m as=0 ps=0 w=10u l=0.5u
X34 ACTB OVRB VDD VDD pfet_03v3 ad=1.76p pd=9.76u as=0 ps=0 w=2u l=0.28u
X35 VREF NB VSS VSS nfet_03v3 ad=0 pd=0 as=0 ps=0 w=20u l=2u
X36 VDD X VREF VSS nfet_03v3 ad=0 pd=0 as=0 ps=0 w=10u l=0.5u
X37 X ACTB VSS VSS nfet_03v3 ad=0 pd=0 as=0 ps=0 w=1u l=0.5u
X38 YB Y VDD VDD pfet_03v3 ad=0.88p pd=4.88u as=0 ps=0 w=2u l=0.28u
X39 VREF NB VSS VSS nfet_03v3 ad=0 pd=0 as=0 ps=0 w=20u l=2u
X40 VREF NB VSS VSS nfet_03v3 ad=0 pd=0 as=0 ps=0 w=20u l=2u
X41 VDD X VREF VSS nfet_03v3 ad=0 pd=0 as=0 ps=0 w=10u l=0.5u
X42 NB NB VSS VSS nfet_03v3 ad=1.76p pd=8.88u as=1.76p ps=8.88u w=4u l=2u
X43 VREF NB VSS VSS nfet_03v3 ad=0 pd=0 as=0 ps=0 w=20u l=2u
X44 VREF NB VSS VSS nfet_03v3 ad=0 pd=0 as=0 ps=0 w=20u l=2u
X45 READY ACTB VSS VSS nfet_03v3 ad=0.88p pd=5.76u as=0 ps=0 w=1u l=0.28u
X46 YB Y VSS VSS nfet_03v3 ad=0.44p pd=2.88u as=0 ps=0 w=1u l=0.28u
X47 VREF NB VSS VSS nfet_03v3 ad=0 pd=0 as=0 ps=0 w=20u l=2u
X48 Y VREF0 TC VSS nfet_03v3 ad=0 pd=0 as=0 ps=0 w=8u l=1u
X49 YA YA VDDA VDD pfet_03v3 ad=1.76p pd=8.88u as=0 ps=0 w=4u l=1u
X50 VREF VSS cap_mim_2f0_m4m5_noshield c_width=70.7u c_length=70.7u
X51 VREF VSS cap_mim_2f0_m4m5_noshield c_width=70.7u c_length=70.7u
X52 X VSS cap_mim_2f0_m4m5_noshield c_width=70.7u c_length=70.7u
X53 TC NB VSS VSS nfet_03v3 ad=0 pd=0 as=0 ps=0 w=4u l=2u
X54 VREF VSS cap_mim_2f0_m4m5_noshield c_width=70.7u c_length=70.7u
X55 VREF VSS cap_mim_2f0_m4m5_noshield c_width=70.7u c_length=70.7u
C0 NB READY 1.93934f
C1 ACTB YA 1.03003f
C2 X VDDA 0.39118f
C3 VDD NB 0.99909f
C4 READY NA_m 0.09928f
C5 ACTB YB 0.38078f
C6 YA VDDA 2.07667f
C7 NB X 5.59502f
C8 YB NR_m 0.03811f
C9 VDD NA_m 0.63983f
C10 VREF VREF0 5.72315f
C11 VREF0 TC 0.18308f
C12 NB YA 0
C13 READY EN 0.04606f
C14 VREF ACTB 3.17334f
C15 TC ACTB 0
C16 VDD EN 1.59396f
C17 VREF VDDA 0
C18 X EN 0.05506f
C19 TC VDDA 0.00439f
C20 OVRB Y 1.65666f
C21 NB VREF 17.88223f
C22 NB TC 0.14036f
C23 VREF0 ACTB 0.11326f
C24 OVR Y 0.01626f
C25 VREF0 VDDA 0.00472f
C26 ACTB NR_m 0.03898f
C27 NB VREF0 0.25786f
C28 VREF EN 8.96069f
C29 ACTB VDDA 0.25132f
C30 NB ACTB 0.1561f
C31 NA_m ACTB 1.05495f
C32 NB VDDA 0
C33 EN VREF0 0.14775f
C34 EN ACTB 0.16413f
C35 ACT Y 0
C36 NB EN 1.47575f
C37 EN NA_m 0.02151f
C38 OVR OVRB 0.03489f
C39 READY Y 2.0856f
C40 VDD Y 2.35431f
C41 YA Y 0.24622f
C42 XA ACT 0
C43 OVR IBIAS 0.34954f
C44 YB Y 0.09812f
C45 OVRB ACT 0
C46 TN XA 0.98809f
C47 VREF Y 1.94534f
C48 TC Y 0.47879f
C49 READY XA 0.3443f
C50 VDD XA 4.44389f
C51 VREF0 Y 0.18308f
C52 X XA 0.34937f
C53 READY OVRB 0.97532f
C54 ACT IBIAS 0.05844f
C55 ACTB Y 0.3936f
C56 VDD OVRB 3.07133f
C57 READY OVR 0.81312f
C58 Y VDDA 0.56061f
C59 VDD OVR 1.6594f
C60 OVR X 0.17901f
C61 NA_m Y 0.07248f
C62 VREF XA 0.02295f
C63 READY IBIAS 0.04479f
C64 VREF OVRB 0.7892f
C65 EN Y 0.67928f
C66 VDD IBIAS 0.15208f
C67 XA VREF0 0.22547f
C68 X IBIAS 0.05476f
C69 OVR VREF 0.95638f
C70 READY ACT 0.17777f
C71 XA ACTB 0.04208f
C72 VDD ACT 7.24721f
C73 XA VDDA 1.27704f
C74 X ACT 0.00199f
C75 OVR VREF0 1.19339f
C76 OVRB ACTB 1.10075f
C77 READY TN 0.7924f
C78 ACT YA 0.11645f
C79 NB XA 0
C80 VREF IBIAS 0.13151f
C81 VDD TN 0.02001f
C82 ACT YB 0
C83 OVR ACTB 0.13222f
C84 TN X 0.67237f
C85 OVRB NA_m 0.21265f
C86 VREF ACT 0.44497f
C87 NB OVR 2.68373f
C88 VREF0 IBIAS 0
C89 TC ACT 0.11501f
C90 VDD READY 1.30762f
C91 READY X 4.48249f
C92 OVR NA_m 0
C93 OVRB EN 0.39781f
C94 VDD X 1.51741f
C95 READY YA 0.21306f
C96 TN VREF 0.22547f
C97 VDD YA 3.3915f
C98 READY YB 0.76717f
C99 VREF0 ACT 0.04482f
C100 OVR EN 7.48707f
C101 VDD YB 2.90144f
C102 NB IBIAS 1.72438f
C103 ACTB ACT 3.55674f
C104 TN VREF0 0.22815f
C105 READY VREF 0.13165f
C106 READY TC 1.01041f
C107 ACT VDDA 0.05784f
C108 VDD VREF 20.16051f
C109 VDD TC 0.00796f
C110 NB ACT 0.23802f
C111 TN ACTB 0.00172f
C112 VREF X 9.11312f
C113 X TC 0.00507f
C114 EN IBIAS 0.68717f
C115 VREF YA 0.38867f
C116 NA_m ACT 0.50033f
C117 TC YA 1.21823f
C118 TN VDDA 0.00456f
C119 READY VREF0 0.77717f
C120 VREF YB 0.67348f
C121 VDD VREF0 5.92077f
C122 NB TN 0.26414f
C123 X VREF0 2.04695f
C124 READY ACTB 1.01883f
C125 READY NR_m 1.14857f
C126 VREF0 YA 0.17976f
C127 VDD ACTB 9.12658f
C128 READY VDDA 3.51993f
C129 VDD NR_m 2.01535f
C130 VREF TC 0.38809f
C131 X ACTB 0.02493f
C132 VDD VDDA 4.73444f
C133 TC VSS 4.6636f $ **FLOATING
C134 YA VSS 6.13421f $ **FLOATING
C135 YB VSS 7.20022f $ **FLOATING
C136 IBIAS VSS 1.67532f
C137 ACT VSS 12.55414f $ **FLOATING
C138 VDD VSS 82.44204f
C139 X VSS 86.22919f $ **FLOATING
C140 ACTB VSS 19.34742f $ **FLOATING
C141 NB VSS 74.74726f $ **FLOATING
C142 NA_m VSS 3.15529f $ **FLOATING
C143 EN VSS 8.04027f
C144 OVRB VSS 6.23734f $ **FLOATING
C145 OVR VSS 12.8055f
C146 VREF VSS 0.66796p
C147 READY VSS 3.39321f
C148 Y VSS 10.40236f $ **FLOATING
C149 VREF0 VSS 6.43873f
C150 TN VSS 4.10448f $ **FLOATING
C151 NR_m VSS 0.43707f $ **FLOATING
C152 XA VSS 4.37511f $ **FLOATING
C153 VDDA VSS 1.91164f $ **FLOATING
.ends
