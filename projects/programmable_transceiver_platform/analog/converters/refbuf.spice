* pt_refbuf: transistor-level schematic of converter block refbuf (gf180mcuD).
* Generated by analog/converters/flow.py from circuits.py; do not edit.
* Standard cells: include /pdk/gf180mcuD/libs.ref/gf180mcu_fd_sc_mcu7t5v0/spice/gf180mcu_fd_sc_mcu7t5v0.spice
.subckt pt_refbuf VDD VSS VREF0 VREF IBIAS EN OVR READY
XION_0 OVRB OVR VSS VSS nfet_03v3 w=1.0u l=0.28u
XIOP_0 OVRB OVR VDD VDD pfet_03v3 w=2.0u l=0.28u
XNANA_0 ACTB EN NA_m VSS nfet_03v3 w=2.0u l=0.28u
XNANB_0 NA_m OVRB VSS VSS nfet_03v3 w=2.0u l=0.28u
XNAPA_0 ACTB EN VDD VDD pfet_03v3 w=2.0u l=0.28u
XNAPB_0 ACTB OVRB VDD VDD pfet_03v3 w=2.0u l=0.28u
XIAN_0 ACT ACTB VSS VSS nfet_03v3 w=1.0u l=0.28u
XIAP_0 ACT ACTB VDD VDD pfet_03v3 w=2.0u l=0.28u
XMSW_0 IBIAS ACT NB VSS nfet_03v3 w=4u l=0.5u
XMD_0 NB NB VSS VSS nfet_03v3 w=4u l=2u
XMPD_0 NB ACTB VSS VSS nfet_03v3 w=1u l=0.5u
XMT_0 TN NB VSS VSS nfet_03v3 w=8u l=2u
XM1_0 XA VREF0 TN VSS nfet_03v3 w=10u l=1u
XM2_0 X VREF TN VSS nfet_03v3 w=10u l=1u
XMH_0 VDDA ACTB VDD VDD pfet_03v3 w=8u l=0.28u
XM3_0 XA XA VDDA VDD pfet_03v3 w=4u l=2u
XM4_0 X XA VDDA VDD pfet_03v3 w=4u l=2u
XMXD_0 X ACTB VSS VSS nfet_03v3 w=1u l=0.5u
XMF_0 VDD X VREF VSS nfet_03v3 w=10u l=0.5u
XMF_1 VDD X VREF VSS nfet_03v3 w=10u l=0.5u
XMF_2 VDD X VREF VSS nfet_03v3 w=10u l=0.5u
XMF_3 VDD X VREF VSS nfet_03v3 w=10u l=0.5u
XMS_0 VREF NB VSS VSS nfet_03v3 w=20u l=2u
XMS_1 VREF NB VSS VSS nfet_03v3 w=20u l=2u
XMS_2 VREF NB VSS VSS nfet_03v3 w=20u l=2u
XMS_3 VREF NB VSS VSS nfet_03v3 w=20u l=2u
XMS_4 VREF NB VSS VSS nfet_03v3 w=20u l=2u
XMS_5 VREF NB VSS VSS nfet_03v3 w=20u l=2u
XMS_6 VREF NB VSS VSS nfet_03v3 w=20u l=2u
XMS_7 VREF NB VSS VSS nfet_03v3 w=20u l=2u
XMS_8 VREF NB VSS VSS nfet_03v3 w=20u l=2u
XMS_9 VREF NB VSS VSS nfet_03v3 w=20u l=2u
XMTC_0 TC NB VSS VSS nfet_03v3 w=4u l=2u
XMA_0 YA VREF TC VSS nfet_03v3 w=8u l=1u
XMA_1 YA VREF TC VSS nfet_03v3 w=8u l=1u
XMB_0 Y VREF0 TC VSS nfet_03v3 w=8u l=1u
XMC3_0 YA YA VDDA VDD pfet_03v3 w=4u l=1u
XMC4_0 Y YA VDDA VDD pfet_03v3 w=4u l=1u
XMYD_0 Y ACTB VSS VSS nfet_03v3 w=1u l=0.5u
XIYN_0 YB Y VSS VSS nfet_03v3 w=1.0u l=0.28u
XIYP_0 YB Y VDD VDD pfet_03v3 w=2.0u l=0.28u
XNRNA_0 READY YB VSS VSS nfet_03v3 w=1.0u l=0.28u
XNRNB_0 READY ACTB VSS VSS nfet_03v3 w=1.0u l=0.28u
XNRPA_0 NR_m YB VDD VDD pfet_03v3 w=4.0u l=0.28u
XNRPB_0 READY ACTB NR_m VDD pfet_03v3 w=4.0u l=0.28u
XCC_0 X VSS cap_mim_2f0_m4m5_noshield c_width=70.7u c_length=70.7u
XCRA_0 VREF VSS cap_mim_2f0_m4m5_noshield c_width=70.7u c_length=70.7u
XCRA_1 VREF VSS cap_mim_2f0_m4m5_noshield c_width=70.7u c_length=70.7u
XCRA_2 VREF VSS cap_mim_2f0_m4m5_noshield c_width=70.7u c_length=70.7u
XCRA_3 VREF VSS cap_mim_2f0_m4m5_noshield c_width=70.7u c_length=70.7u
XCRA_4 VREF VSS cap_mim_2f0_m4m5_noshield c_width=70.7u c_length=70.7u
XCRB_0 VREF VSS cap_mim_2f0_m4m5_noshield c_width=70.7u c_length=70.7u
XCRB_1 VREF VSS cap_mim_2f0_m4m5_noshield c_width=70.7u c_length=70.7u
XCRB_2 VREF VSS cap_mim_2f0_m4m5_noshield c_width=70.7u c_length=70.7u
XCRB_3 VREF VSS cap_mim_2f0_m4m5_noshield c_width=70.7u c_length=70.7u
XCRB_4 VREF VSS cap_mim_2f0_m4m5_noshield c_width=70.7u c_length=70.7u
.ends
