* NGSPICE file created from gf180mcu_ocd_ip__bandgap.ext - technology: gf180mcuD

.subckt gf180mcu_ocd_ip__bandgap dvdd vbg dvss ibias1_250n trim[15] trim[14] trim[13]
+ trim[12] trim[11] trim[10] trim[9] trim[8] trim[7] trim[6] trim[5] trim[4] trim[3]
+ trim[2] trim[1] trim[0] ena ibias2_1u
X0 x1.xamp.vbn1 x1.xamp.vbn1 dvss.t112 dvss.t359 nfet_03v3 ad=0.43415p pd=2.88u as=0.43415p ps=2.88u w=1u l=1u
X1 x1.xamp.out1n x1.xamp.inp x1.xamp.pfet_03v3_VL4T3E_0.S1_0 dvdd.t35 pfet_03v3 ad=1.76p pd=8.88u as=1.76p ps=8.88u w=4u l=1u
X2 gf180mcu_ocd_ip__classab_buffer_0.se_folded_cascode_np_ab_0.diffb gf180mcu_ocd_ip__classab_buffer_0.se_folded_cascode_np_ab_0.vbp1 dvdd.t42 dvdd.t44 pfet_03v3 ad=0.44p pd=2.88u as=0.44p ps=2.88u w=1u l=1u
X3 x1.xtr.nfet_03v3_GP977X_0.S9 x1.xtr.nfet_03v3_GP977X_0.S10 dvss.t3 ppolyf_u r_width=1u r_length=2.63u
X4 dvss.t170 dvss.t169 dvss.t170 dvss.t162 nfet_03v3 ad=0.88p pd=4.88u as=0 ps=0 w=2u l=4u
X5 dvss.t145 dvss.t145 dvss.t145 dvss.t75 nfet_03v3 ad=0.44p pd=2.88u as=0 ps=0 w=1u l=1u
X6 x1.xamp.out1n x1.xamp.inp x1.xamp.pfet_03v3_VL4T3E_0.S1_0 dvdd.t33 pfet_03v3 ad=1.76p pd=8.88u as=1.76p ps=8.88u w=4u l=1u
X7 x1.xamp.pfet_03v3_VL4T3E_0.S1_0 x1.xamp.vbp1.t28 dvdd.t70 dvdd.t69 pfet_03v3 ad=0.44p pd=2.88u as=0.44p ps=2.88u w=1u l=1u
X8 dvdd.t223 a_n8227_n17722# x1.gf180mcu_as_sc_mcu7t3v3__buff_2_13.Y dvdd.t222 pfet_03v3 ad=0.3588p pd=1.9u as=0.3588p ps=1.9u w=1.38u l=0.28u
X9 x1.xtr.nfet_03v3_GP977X_0.S9 x1.xtr.nfet_03v3_GP977X_0.S10 dvss.t3 ppolyf_u r_width=1u r_length=2.63u
D0 dvss.t51 trim[11] diode_nd2ps_03v3 pj=1.83u area=0.209p
X10 dvss.t171 dvss.t171 dvss.t171 dvss.t172 nfet_03v3 ad=0.44p pd=2.88u as=0 ps=0 w=1u l=1u
X11 gf180mcu_ocd_ip__classab_buffer_0.se_folded_cascode_np_ab_0.nfet_03v3_XHQ8ZW_0.S0_0 vbg gf180mcu_ocd_ip__classab_buffer_0.se_folded_cascode_np_ab_0.outa1n.t43 dvss.t75 nfet_03v3 ad=0.88p pd=4.88u as=0.88p ps=4.88u w=2u l=1u
D1 dvss.t330 trim[2] diode_nd2ps_03v3 pj=1.83u area=0.209p
X12 gf180mcu_ocd_ip__classab_buffer_0.se_folded_cascode_np_ab_0.outa1p.t12 gf180mcu_ocd_ip__classab_buffer_0.se_folded_cascode_np_ab_0.pfet_03v3_9TM96F_0.G0_0 gf180mcu_ocd_ip__classab_buffer_0.se_folded_cascode_np_ab_0.pfet_03v3_XWLNX2_0.D.t1 dvdd.t23 pfet_03v3 ad=0.44p pd=2.88u as=0.44p ps=2.88u w=1u l=4u
X13 gf180mcu_ocd_ip__classab_buffer_0.se_folded_cascode_np_ab_0.vbp1 ibias2_1u ibias2_1u dvdd.t142 pfet_03v3 ad=0.4257p pd=2.88u as=0.4257p ps=2.88u w=1u l=0.5u
X14 x1.xamp.pfet_03v3_VL4T3E_0.S1_0 x1.xamp.vbp1.t23 dvdd.t70 dvdd.t69 pfet_03v3 ad=0.44p pd=2.88u as=0.44p ps=2.88u w=1u l=1u
X15 a_n8227_n18618# trim[12] dvdd.t76 dvdd.t278 pfet_03v3 ad=0.6072p pd=3.64u as=0.3588p ps=1.9u w=1.38u l=0.28u
X16 ibias2_1u x1.ena_buf dvdd.t48 dvdd.t215 pfet_03v3 ad=0.4231p pd=2.88u as=0.4231p ps=2.88u w=1u l=0.28u
X17 a_n8227_n29594# trim[0] dvss.t60 dvss.t309 nfet_03v3 ad=0.44p pd=2.88u as=0.26p ps=1.52u w=1u l=0.28u
X18 x1.xamp.pfet_03v3_VL4T3E_0.S1_0 x1.xamp.vbp1.t18 dvdd.t70 dvdd.t69 pfet_03v3 ad=0.44p pd=2.88u as=0.44p ps=2.88u w=1u l=1u
X19 dvss.t24 dvss.t24 x1.pnp_05p00x05p00_0_0[0|0].E pnp_05p00x05p00
**devattr s=1000000,4000 d=225453094,146072
X20 dvdd.t81 a_n8227_n29594# x1.gf180mcu_as_sc_mcu7t3v3__buff_2_0.Y dvdd.t135 pfet_03v3 ad=0.3588p pd=1.9u as=0.3588p ps=1.9u w=1.38u l=0.28u
X21 dvdd.t244 x1.xamp.pfet_03v3_EQVFPB_0.G1_0.t34 x1.xamp.pfet_03v3_EQVFPB_0.S1_0 dvdd.t77 pfet_03v3 ad=0.87415p pd=4.88u as=0.87415p ps=4.88u w=2u l=4u
X22 x1.xtr.top x1.xtr.top dvss.t39 ppolyf_u r_width=1u r_length=2.63u
X23 x1.xtr.nfet_03v3_GP977X_0.S2 x1.xtr.nfet_03v3_GP977X_0.S3 dvss.t255 ppolyf_u r_width=1u r_length=2.63u
X24 x1.xtr.nfet_03v3_GP977X_0.S2 x1.xtr.nfet_03v3_GP977X_0.S3 dvss.t255 ppolyf_u r_width=1u r_length=2.63u
X25 x1.nfet_03v3_EV2W8D_0.S1.t0 x1.xamp.vbn2 x1.xamp.out1p dvss.t318 nfet_03v3 ad=0.43415p pd=2.88u as=0.43415p ps=2.88u w=1u l=4u
X26 gf180mcu_ocd_ip__classab_buffer_0.se_folded_cascode_np_ab_0.outb1p gf180mcu_ocd_ip__classab_buffer_0.se_folded_cascode_np_ab_0.vbn1 dvss.t204 dvss.t203 nfet_03v3 ad=0.44p pd=2.88u as=0.44p ps=2.88u w=1u l=1u
X27 dvss.t279 x1.ena_buf gf180mcu_ocd_ip__classab_buffer_0.se_folded_cascode_np_ab_0.nfet_03v3_XRMCLC_0.S0_0 dvss.t286 nfet_03v3 ad=1.73465p pd=8.88u as=1.73465p ps=8.88u w=4u l=0.28u
X28 dvdd.t297 x1.xamp.pfet_03v3_EQVFPB_0.G1_0.t39 x1.xamp.pfet_03v3_EQVFPB_0.S1_1 dvdd.t37 pfet_03v3 ad=0.87415p pd=4.88u as=0.87415p ps=4.88u w=2u l=4u
X29 x1.xamp.out1p x1.xamp.vbn1 dvss.t83 dvss.t382 nfet_03v3 ad=0.43415p pd=2.88u as=0.43415p ps=2.88u w=1u l=1u
X30 gf180mcu_ocd_ip__classab_buffer_0.se_folded_cascode_np_ab_0.outb1p gf180mcu_ocd_ip__classab_buffer_0.se_folded_cascode_np_ab_0.vbn1 dvss.t180 dvss.t214 nfet_03v3 ad=0.44p pd=2.88u as=0.44p ps=2.88u w=1u l=1u
X31 gf180mcu_ocd_ip__classab_buffer_0.se_folded_cascode_np_ab_0.outa1p.t13 gf180mcu_ocd_ip__classab_buffer_0.se_folded_cascode_np_ab_0.pfet_03v3_9TM96F_0.G0_0 gf180mcu_ocd_ip__classab_buffer_0.se_folded_cascode_np_ab_0.pfet_03v3_XWLNX2_0.D.t9 dvdd.t25 pfet_03v3 ad=0.44p pd=2.88u as=0.44p ps=2.88u w=1u l=4u
X32 x1.xtr.nfet_03v3_GP977X_0.S2 x1.gf180mcu_as_sc_mcu7t3v3__buff_2_13.Y x1.pnp_05p00x05p00_0_0[0|0].E.t29 dvss.t302 nfet_03v3 ad=1.2964p pd=7.08u as=1.2964p ps=7.08u w=3.1u l=0.28u
X33 dvss.t118 dvss.t112 dvss.t117 dvss.t113 nfet_03v3 ad=0.43415p pd=2.88u as=0 ps=0 w=1u l=1u
X34 gf180mcu_ocd_ip__classab_buffer_0.se_folded_cascode_np_ab_0.diffb gf180mcu_ocd_ip__classab_buffer_0.se_folded_cascode_np_ab_0.vbp1 dvdd.t48 dvdd.t49 pfet_03v3 ad=0.44p pd=2.88u as=0.44p ps=2.88u w=1u l=1u
D2 dvss.t313 trim[7] diode_nd2ps_03v3 pj=1.83u area=0.209p
D3 trim[12] dvdd.t276 diode_pd2nw_03v3 pj=1.93u area=0.2295p
X35 a_n8227_n25114# trim[5] dvss.t242 dvss.t329 nfet_03v3 ad=0.44p pd=2.88u as=0.26p ps=1.52u w=1u l=0.28u
X36 x1.xtr.nfet_03v3_GP977X_0.S5 x1.xtr.nfet_03v3_GP977X_0.S6 dvss.t40 ppolyf_u r_width=1u r_length=2.63u
X37 x1.xtr.nfet_03v3_GP977X_0.S8 x1.xtr.nfet_03v3_GP977X_0.S9 dvss.t1 ppolyf_u r_width=1u r_length=2.63u
X38 x1.xamp.out1p x1.xamp.vbn1 dvss.t112 dvss.t364 nfet_03v3 ad=0.43415p pd=2.88u as=0.43415p ps=2.88u w=1u l=1u
X39 x1.xtr.nfet_03v3_GP977X_0.S8 x1.xtr.nfet_03v3_GP977X_0.S9 dvss.t1 ppolyf_u r_width=1u r_length=2.63u
X40 x1.nfet_03v3_EV2W8D_0.S1.t5 x1.xamp.vbn2 x1.xamp.out1p dvss.t322 nfet_03v3 ad=0.43415p pd=2.88u as=0.43415p ps=2.88u w=1u l=4u
X41 dvdd.t258 x1.xamp.pfet_03v3_EQVFPB_0.G1_0.t31 x1.xamp.pfet_03v3_EQVFPB_0.S1_1 dvdd.t37 pfet_03v3 ad=0.87415p pd=4.88u as=0.87415p ps=4.88u w=2u l=4u
X42 dvdd.t117 a_n8227_n25114# x1.gf180mcu_as_sc_mcu7t3v3__buff_2_5.Y dvdd.t116 pfet_03v3 ad=0.3588p pd=1.9u as=0.3588p ps=1.9u w=1.38u l=0.28u
X43 a_n3700_n17599# a_n598_n17039# dvss.t56 ppolyf_u r_width=1u r_length=15u
X44 dvss.t166 dvss.t167 dvss.t166 dvss.t162 nfet_03v3 ad=0.88p pd=4.88u as=0 ps=0 w=2u l=4u
X45 a_n8227_n26010# trim[4] dvdd.t117 dvdd.t241 pfet_03v3 ad=0.6072p pd=3.64u as=0.3588p ps=1.9u w=1.38u l=0.28u
X46 gf180mcu_ocd_ip__classab_buffer_0.se_folded_cascode_np_ab_0.nfet_03v3_XHQ8ZW_0.S0_0 x1.vbg gf180mcu_ocd_ip__classab_buffer_0.se_folded_cascode_np_ab_0.outa1p.t28 dvss.t73 nfet_03v3 ad=0.88p pd=4.88u as=0.88p ps=4.88u w=2u l=1u
X47 x1.xtr.nfet_03v3_GP977X_0.S6 x1.xtr.nfet_03v3_GP977X_0.S7 dvss.t18 ppolyf_u r_width=1u r_length=2.63u
X48 dvss.t136 dvss.t128 dvss.t135 dvss.t84 nfet_03v3 ad=0.43415p pd=2.88u as=0 ps=0 w=1u l=1u
X49 gf180mcu_ocd_ip__classab_buffer_0.se_folded_cascode_np_ab_0.outa1n.t39 gf180mcu_ocd_ip__classab_buffer_0.se_folded_cascode_np_ab_0.outa1n.t38 dvdd.t14 dvdd.t72 pfet_03v3 ad=0.44p pd=2.88u as=0.44p ps=2.88u w=1u l=1u
X50 gf180mcu_ocd_ip__classab_buffer_0.se_folded_cascode_np_ab_0.outa1p.t11 gf180mcu_ocd_ip__classab_buffer_0.se_folded_cascode_np_ab_0.pfet_03v3_9TM96F_0.G0_0 gf180mcu_ocd_ip__classab_buffer_0.se_folded_cascode_np_ab_0.pfet_03v3_XWLNX2_0.D.t8 dvdd.t21 pfet_03v3 ad=0.44p pd=2.88u as=0.44p ps=2.88u w=1u l=4u
X51 gf180mcu_ocd_ip__classab_buffer_0.se_folded_cascode_np_ab_0.outb1n gf180mcu_ocd_ip__classab_buffer_0.se_folded_cascode_np_ab_0.vbn1 dvss.t180 dvss.t194 nfet_03v3 ad=0.44p pd=2.88u as=0.44p ps=2.88u w=1u l=1u
X52 gf180mcu_ocd_ip__classab_buffer_0.se_folded_cascode_np_ab_0.outb1p gf180mcu_ocd_ip__classab_buffer_0.se_folded_cascode_np_ab_0.vbn2 gf180mcu_ocd_ip__classab_buffer_0.se_folded_cascode_np_ab_0.pfet_03v3_XWLNX2_0.D.t25 dvss.t402 nfet_03v3 ad=0.88p pd=4.88u as=0.88p ps=4.88u w=2u l=4u
X53 dvss.t171 dvss.t171 dvss.t171 dvss.t173 nfet_03v3 ad=0.44p pd=2.88u as=0 ps=0 w=1u l=1u
X54 dvss.t140 dvss.t140 dvss.t142 dvss.t141 nfet_03v3 ad=0.43415p pd=2.88u as=0 ps=0 w=1u l=2u
D4 trim[4] dvdd.t239 diode_pd2nw_03v3 pj=1.93u area=0.2295p
D5 dvss.t266 trim[9] diode_nd2ps_03v3 pj=1.83u area=0.209p
X55 x1.xtr.nfet_03v3_GP977X_0.S7 x1.xtr.nfet_03v3_GP977X_0.S8 dvss.t32 ppolyf_u r_width=1u r_length=2.63u
X56 a_n8227_n20410# trim[10] dvdd.t7 dvdd.t123 pfet_03v3 ad=0.6072p pd=3.64u as=0.3588p ps=1.9u w=1.38u l=0.28u
X57 x1.pfet_03v3_BWTVHK_0.D dvss.t63 cap_mim_2f0_m4m5_noshield c_width=22u c_length=22u
D6 dvss.t339 ena diode_nd2ps_03v3 pj=1.83u area=0.209p
X58 x1.xtr.nfet_03v3_GP977X_0.S10 x1.xtr.nfet_03v3_GP977X_0.S11 dvss.t28 ppolyf_u r_width=1u r_length=2.63u
X59 x1.xtr.nfet_03v3_GP977X_0.S10 x1.xtr.nfet_03v3_GP977X_0.S11 dvss.t28 ppolyf_u r_width=1u r_length=2.63u
X60 a_n3700_n20959# a_n598_n21519# dvss.t49 ppolyf_u r_width=1u r_length=15u
X61 x1.nfet_03v3_EV2W8D_0.S1.t21 ibias1_250n x1.xamp.pfet_03v3_EQVFPB_0.S1_0 dvdd.t253 pfet_03v3 ad=0.86765p pd=4.88u as=0.86765p ps=4.88u w=2u l=0.5u
X62 a_n3700_n18719# a_n598_n18159# dvss.t349 ppolyf_u r_width=1u r_length=15u
X63 x1.xamp.out1n x1.xamp.inp x1.xamp.pfet_03v3_VL4T3E_0.S1_0 dvdd.t35 pfet_03v3 ad=1.76p pd=8.88u as=1.76p ps=8.88u w=4u l=1u
X64 dvdd.t223 a_n8227_n16826# x1.gf180mcu_as_sc_mcu7t3v3__buff_2_14.Y dvdd.t225 pfet_03v3 ad=0.3588p pd=1.9u as=0.3588p ps=1.9u w=1.38u l=0.28u
X65 dvss.t166 dvss.t164 dvss.t165 dvss.t162 nfet_03v3 ad=0.88p pd=4.88u as=0 ps=0 w=2u l=4u
X66 dvss.t145 dvss.t145 dvss.t145 dvss.t73 nfet_03v3 ad=0.44p pd=2.88u as=0 ps=0 w=1u l=1u
X67 dvss.t257 a_n8227_n27802# x1.gf180mcu_as_sc_mcu7t3v3__buff_2_2.Y dvss.t256 nfet_03v3 ad=0.26p pd=1.52u as=0.26p ps=1.52u w=1u l=0.28u
X68 gf180mcu_ocd_ip__classab_buffer_0.se_folded_cascode_np_ab_0.nfet_03v3_XHQ8ZW_0.S0_0 vbg gf180mcu_ocd_ip__classab_buffer_0.se_folded_cascode_np_ab_0.outa1n.t41 dvss.t73 nfet_03v3 ad=0.88p pd=4.88u as=0.88p ps=4.88u w=2u l=1u
X69 gf180mcu_ocd_ip__classab_buffer_0.se_folded_cascode_np_ab_0.vbp1 ibias2_1u ibias2_1u dvdd.t143 pfet_03v3 ad=0.4257p pd=2.88u as=0.4257p ps=2.88u w=1u l=0.5u
D7 dvss.t269 trim[3] diode_nd2ps_03v3 pj=1.83u area=0.209p
X70 gf180mcu_ocd_ip__classab_buffer_0.se_folded_cascode_np_ab_0.outa1p.t34 gf180mcu_ocd_ip__classab_buffer_0.se_folded_cascode_np_ab_0.outa1n.t58 dvdd.t16 dvdd.t290 pfet_03v3 ad=0.44p pd=2.88u as=0.44p ps=2.88u w=1u l=1u
X71 gf180mcu_ocd_ip__classab_buffer_0.se_folded_cascode_np_ab_0.outb1p gf180mcu_ocd_ip__classab_buffer_0.se_folded_cascode_np_ab_0.vbn2 gf180mcu_ocd_ip__classab_buffer_0.se_folded_cascode_np_ab_0.pfet_03v3_XWLNX2_0.D.t23 dvss.t398 nfet_03v3 ad=0.88p pd=4.88u as=0.88p ps=4.88u w=2u l=4u
X72 gf180mcu_ocd_ip__classab_buffer_0.se_folded_cascode_np_ab_0.diffb gf180mcu_ocd_ip__classab_buffer_0.se_folded_cascode_np_ab_0.vbp1 dvdd.t42 dvdd.t45 pfet_03v3 ad=0.44p pd=2.88u as=0.44p ps=2.88u w=1u l=1u
X73 x1.gf180mcu_as_sc_mcu7t3v3__buff_2_2.Y a_n8227_n27802# dvdd.t131 dvdd.t132 pfet_03v3 ad=0.3588p pd=1.9u as=1.0488p ps=4.28u w=1.38u l=0.28u
X74 a_n8227_n28698# trim[1] dvss.t60 dvss.t251 nfet_03v3 ad=0.44p pd=2.88u as=0.26p ps=1.52u w=1u l=0.28u
X75 x1.xamp.pfet_03v3_EQVFPB_0.G1_0.t7 x1.xamp.vbn2 x1.xamp.out1n dvss.t323 nfet_03v3 ad=0.43415p pd=2.88u as=0.43415p ps=2.88u w=1u l=4u
X76 x1.xtr.nfet_03v3_GP977X_0.S11 x1.xtr.nfet_03v3_GP977X_0.S12 dvss.t20 ppolyf_u r_width=1u r_length=2.63u
X77 x1.xtr.nfet_03v3_GP977X_0.S11 x1.xtr.nfet_03v3_GP977X_0.S12 dvss.t20 ppolyf_u r_width=1u r_length=2.63u
X78 gf180mcu_ocd_ip__classab_buffer_0.se_folded_cascode_np_ab_0.outb1n gf180mcu_ocd_ip__classab_buffer_0.se_folded_cascode_np_ab_0.vbn1 dvss.t180 dvss.t212 nfet_03v3 ad=0.44p pd=2.88u as=0.44p ps=2.88u w=1u l=1u
X79 dvdd.t81 a_n8227_n28698# x1.gf180mcu_as_sc_mcu7t3v3__buff_2_1.Y dvdd.t80 pfet_03v3 ad=0.3588p pd=1.9u as=0.3588p ps=1.9u w=1.38u l=0.28u
X80 gf180mcu_ocd_ip__classab_buffer_0.se_folded_cascode_np_ab_0.nfet_03v3_XHQ8ZW_0.S0_0 x1.vbg gf180mcu_ocd_ip__classab_buffer_0.se_folded_cascode_np_ab_0.outa1p.t29 dvss.t74 nfet_03v3 ad=0.88p pd=4.88u as=0.88p ps=4.88u w=2u l=1u
X81 dvdd.t168 dvdd.t166 dvdd.t168 dvdd.t167 pfet_03v3 ad=0.44p pd=2.88u as=0 ps=0 w=1u l=4u
X82 ibias1_250n ibias1_250n x1.xamp.vbp1.t12 dvdd.t249 pfet_03v3 ad=0.86765p pd=4.88u as=0.86765p ps=4.88u w=2u l=0.5u
X83 gf180mcu_ocd_ip__classab_buffer_0.se_folded_cascode_np_ab_0.outb1p gf180mcu_ocd_ip__classab_buffer_0.se_folded_cascode_np_ab_0.vbn2 gf180mcu_ocd_ip__classab_buffer_0.se_folded_cascode_np_ab_0.pfet_03v3_XWLNX2_0.D.t24 dvss.t400 nfet_03v3 ad=0.88p pd=4.88u as=0.88p ps=4.88u w=2u l=4u
X84 gf180mcu_ocd_ip__classab_buffer_0.se_folded_cascode_np_ab_0.outa1p.t18 gf180mcu_ocd_ip__classab_buffer_0.se_folded_cascode_np_ab_0.outa1n.t53 dvdd.t14 dvdd.t30 pfet_03v3 ad=0.44p pd=2.88u as=0.44p ps=2.88u w=1u l=1u
X85 gf180mcu_ocd_ip__classab_buffer_0.se_folded_cascode_np_ab_0.outb1p gf180mcu_ocd_ip__classab_buffer_0.se_folded_cascode_np_ab_0.vbn1 dvss.t180 dvss.t213 nfet_03v3 ad=0.44p pd=2.88u as=0.44p ps=2.88u w=1u l=1u
X86 x1.xtr.nfet_03v3_GP977X_0.S15 x1.gf180mcu_as_sc_mcu7t3v3__buff_2_0.Y x1.pnp_05p00x05p00_0_0[0|0].E.t25 dvss.t262 nfet_03v3 ad=1.2964p pd=7.08u as=1.2964p ps=7.08u w=3.1u l=0.28u
X87 x1.xtr.nfet_03v3_GP977X_0.S12 x1.xtr.nfet_03v3_GP977X_0.S13 dvss.t41 ppolyf_u r_width=1u r_length=2.63u
D8 trim[13] dvdd.t267 diode_pd2nw_03v3 pj=1.93u area=0.2295p
X88 dvss.t6 a_n8227_n22202# x1.gf180mcu_as_sc_mcu7t3v3__buff_2_8.Y dvss.t5 nfet_03v3 ad=0.26p pd=1.52u as=0.26p ps=1.52u w=1u l=0.28u
X89 a_n8227_n24218# trim[6] dvss.t2 dvss.t392 nfet_03v3 ad=0.44p pd=2.88u as=0.26p ps=1.52u w=1u l=0.28u
X90 x1.xtr.nfet_03v3_GP977X_0.S9 x1.xtr.nfet_03v3_GP977X_0.S10 dvss.t3 ppolyf_u r_width=1u r_length=2.63u
X91 x1.xtr.nfet_03v3_GP977X_0.S12 x1.xtr.nfet_03v3_GP977X_0.S13 dvss.t41 ppolyf_u r_width=1u r_length=2.63u
X92 x1.xamp.pfet_03v3_EQVFPB_0.G1_0.t11 ibias1_250n x1.xamp.pfet_03v3_EQVFPB_0.S1_1 dvdd.t253 pfet_03v3 ad=0.86765p pd=4.88u as=0.86765p ps=4.88u w=2u l=0.5u
X93 x1.gf180mcu_as_sc_mcu7t3v3__buff_2_8.Y a_n8227_n22202# dvdd.t4 dvdd.t5 pfet_03v3 ad=0.3588p pd=1.9u as=1.0488p ps=4.28u w=1.38u l=0.28u
X94 a_n3700_n19839# a_n598_n19279# dvss.t22 ppolyf_u r_width=1u r_length=15u
X95 dvdd.t296 x1.xamp.pfet_03v3_EQVFPB_0.G1_0.t38 x1.xamp.pfet_03v3_EQVFPB_0.S1_0 dvdd.t77 pfet_03v3 ad=0.87415p pd=4.88u as=0.87415p ps=4.88u w=2u l=4u
X96 x1.xamp.vbn1 x1.xamp.vbn2 x1.xamp.vbn2 dvss.t316 nfet_03v3 ad=0.43415p pd=2.88u as=0.43415p ps=2.88u w=1u l=4u
X97 gf180mcu_ocd_ip__classab_buffer_0.se_folded_cascode_np_ab_0.nfet_03v3_XHQ8ZW_0.S0_0 vbg gf180mcu_ocd_ip__classab_buffer_0.se_folded_cascode_np_ab_0.outa1n.t47 dvss.t71 nfet_03v3 ad=0.88p pd=4.88u as=0.88p ps=4.88u w=2u l=1u
X98 dvdd.t160 dvdd.t158 dvdd.t160 dvdd.t159 pfet_03v3 ad=0.4257p pd=2.88u as=0 ps=0 w=1u l=0.5u
X99 gf180mcu_ocd_ip__classab_buffer_0.se_folded_cascode_np_ab_0.pfet_03v3_9TM96F_0.G0_0 gf180mcu_ocd_ip__classab_buffer_0.se_folded_cascode_np_ab_0.pfet_03v3_9TM96F_0.G0_0 gf180mcu_ocd_ip__classab_buffer_0.se_folded_cascode_np_ab_0.outa1n.t2 dvdd.t22 pfet_03v3 ad=0.44p pd=2.88u as=0.44p ps=2.88u w=1u l=4u
X100 x1.xtr.top x1.xtr.top dvss.t39 ppolyf_u r_width=1u r_length=2.63u
X101 x1.xtr.nfet_03v3_GP977X_0.S2 x1.xtr.nfet_03v3_GP977X_0.S3 dvss.t255 ppolyf_u r_width=1u r_length=2.63u
X102 gf180mcu_ocd_ip__classab_buffer_0.se_folded_cascode_np_ab_0.nfet_03v3_XRMCLC_0.S0_0 gf180mcu_ocd_ip__classab_buffer_0.se_folded_cascode_np_ab_0.pfet_03v3_XWLNX2_0.D.t40 vbg dvss.t21 nfet_03v3 ad=1.76p pd=8.88u as=1.76p ps=8.88u w=4u l=4u
X103 gf180mcu_ocd_ip__classab_buffer_0.se_folded_cascode_np_ab_0.outa1p.t0 gf180mcu_ocd_ip__classab_buffer_0.se_folded_cascode_np_ab_0.outa1n.t49 dvdd.t14 dvdd.t13 pfet_03v3 ad=0.44p pd=2.88u as=0.44p ps=2.88u w=1u l=1u
X104 dvss.t14 a_n8227_n19514# x1.gf180mcu_as_sc_mcu7t3v3__buff_2_11.Y dvss.t297 nfet_03v3 ad=0.26p pd=1.52u as=0.26p ps=1.52u w=1u l=0.28u
X105 x1.xamp.out1p x1.pnp_05p00x05p00_0_0[1|1].E x1.xamp.pfet_03v3_VL4T3E_0.S1_0 dvdd.t36 pfet_03v3 ad=1.76p pd=8.88u as=1.76p ps=8.88u w=4u l=1u
X106 gf180mcu_ocd_ip__classab_buffer_0.se_folded_cascode_np_ab_0.outa1n.t33 gf180mcu_ocd_ip__classab_buffer_0.se_folded_cascode_np_ab_0.outa1n.t32 dvdd.t14 dvdd.t279 pfet_03v3 ad=0.44p pd=2.88u as=0.44p ps=2.88u w=1u l=1u
D9 dvss.t351 trim[12] diode_nd2ps_03v3 pj=1.83u area=0.209p
X107 gf180mcu_ocd_ip__classab_buffer_0.se_folded_cascode_np_ab_0.outa1p.t32 gf180mcu_ocd_ip__classab_buffer_0.se_folded_cascode_np_ab_0.outa1n.t54 dvdd.t14 dvdd.t284 pfet_03v3 ad=0.44p pd=2.88u as=0.44p ps=2.88u w=1u l=1u
X108 x1.nfet_03v3_EV2W8D_0.S1.t3 x1.xamp.vbn2 x1.xamp.out1p dvss.t4 nfet_03v3 ad=0.43415p pd=2.88u as=0.43415p ps=2.88u w=1u l=4u
X109 dvss.t145 dvss.t145 dvss.t145 dvss.t74 nfet_03v3 ad=0.44p pd=2.88u as=0 ps=0 w=1u l=1u
X110 x1.gf180mcu_as_sc_mcu7t3v3__buff_2_11.Y a_n8227_n19514# dvdd.t76 dvdd.t228 pfet_03v3 ad=0.3588p pd=1.9u as=1.0488p ps=4.28u w=1.38u l=0.28u
X111 gf180mcu_ocd_ip__classab_buffer_0.se_folded_cascode_np_ab_0.nfet_03v3_XHQ8ZW_0.S0_0 vbg gf180mcu_ocd_ip__classab_buffer_0.se_folded_cascode_np_ab_0.outa1n.t42 dvss.t74 nfet_03v3 ad=0.88p pd=4.88u as=0.88p ps=4.88u w=2u l=1u
X112 dvdd.t105 x1.xamp.pfet_03v3_EQVFPB_0.G1_0.t30 x1.xamp.pfet_03v3_EQVFPB_0.S1_0 dvdd.t77 pfet_03v3 ad=0.87415p pd=4.88u as=0.87415p ps=4.88u w=2u l=4u
X113 x1.xamp.pfet_03v3_EQVFPB_0.G1_0.t9 ibias1_250n x1.xamp.pfet_03v3_EQVFPB_0.S1_1 dvdd.t253 pfet_03v3 ad=0.86765p pd=4.88u as=0.86765p ps=4.88u w=2u l=0.5u
X114 x1.xtr.nfet_03v3_GP977X_0.S5 x1.xtr.nfet_03v3_GP977X_0.S6 dvss.t40 ppolyf_u r_width=1u r_length=2.63u
X115 x1.xtr.nfet_03v3_GP977X_0.S8 x1.xtr.nfet_03v3_GP977X_0.S9 dvss.t1 ppolyf_u r_width=1u r_length=2.63u
X116 x1.nfet_03v3_EV2W8D_0.S1.t2 x1.xamp.vbn2 x1.xamp.out1p dvss.t320 nfet_03v3 ad=0.43415p pd=2.88u as=0.43415p ps=2.88u w=1u l=4u
X117 gf180mcu_ocd_ip__classab_buffer_0.se_folded_cascode_np_ab_0.outa1p.t35 gf180mcu_ocd_ip__classab_buffer_0.se_folded_cascode_np_ab_0.outa1n.t56 dvdd.t14 dvdd.t291 pfet_03v3 ad=0.44p pd=2.88u as=0.44p ps=2.88u w=1u l=1u
X118 gf180mcu_ocd_ip__classab_buffer_0.se_folded_cascode_np_ab_0.vbn2 gf180mcu_ocd_ip__classab_buffer_0.se_folded_cascode_np_ab_0.vbp1 dvdd.t56 dvdd.t57 pfet_03v3 ad=0.44p pd=2.88u as=0.44p ps=2.88u w=1u l=1u
X119 a_n8227_n17722# trim[13] dvdd.t223 dvdd.t269 pfet_03v3 ad=0.6072p pd=3.64u as=0.3588p ps=1.9u w=1.38u l=0.28u
X120 gf180mcu_ocd_ip__classab_buffer_0.se_folded_cascode_np_ab_0.diffb gf180mcu_ocd_ip__classab_buffer_0.se_folded_cascode_np_ab_0.vbp1 dvdd.t48 dvdd.t47 pfet_03v3 ad=0.44p pd=2.88u as=0.44p ps=2.88u w=1u l=1u
X121 gf180mcu_ocd_ip__classab_buffer_0.se_folded_cascode_np_ab_0.diffb x1.vbg gf180mcu_ocd_ip__classab_buffer_0.se_folded_cascode_np_ab_0.outb1p dvdd.t102 pfet_03v3 ad=1.76p pd=8.88u as=1.76p ps=8.88u w=4u l=1u
X122 dvss.t288 a_n8227_n15034# x1.ena_buf dvss.t287 nfet_03v3 ad=0.26p pd=1.52u as=0.26p ps=1.52u w=1u l=0.28u
X123 dvss.t2 a_n8227_n23322# x1.gf180mcu_as_sc_mcu7t3v3__buff_2_7.Y dvss.t1 nfet_03v3 ad=0.26p pd=1.52u as=0.26p ps=1.52u w=1u l=0.28u
X124 dvdd.t70 dvdd.t70 dvdd.t70 dvdd.t34 pfet_03v3 ad=1.76p pd=8.88u as=0 ps=0 w=4u l=1u
X125 x1.gf180mcu_as_sc_mcu7t3v3__buff_2_7.Y a_n8227_n23322# dvdd.t1 dvdd.t2 pfet_03v3 ad=0.3588p pd=1.9u as=1.0488p ps=4.28u w=1.38u l=0.28u
X126 x1.xtr.nfet_03v3_GP977X_0.S6 x1.xtr.nfet_03v3_GP977X_0.S7 dvss.t18 ppolyf_u r_width=1u r_length=2.63u
X127 gf180mcu_ocd_ip__classab_buffer_0.se_folded_cascode_np_ab_0.outa1p.t19 gf180mcu_ocd_ip__classab_buffer_0.se_folded_cascode_np_ab_0.outa1n.t51 dvdd.t14 dvdd.t39 pfet_03v3 ad=0.44p pd=2.88u as=0.44p ps=2.88u w=1u l=1u
X128 x1.xamp.vbp1.t5 x1.xamp.vbp1.t4 dvdd.t89 dvdd.t69 pfet_03v3 ad=0.44p pd=2.88u as=0.44p ps=2.88u w=1u l=1u
X129 x1.xtr.nfet_03v3_GP977X_0.S12 x1.gf180mcu_as_sc_mcu7t3v3__buff_2_3.Y x1.pnp_05p00x05p00_0_0[0|0].E.t21 dvss.t259 nfet_03v3 ad=1.2964p pd=7.08u as=1.2964p ps=7.08u w=3.1u l=0.28u
X130 a_n3700_n22079# x1.pfet_03v3_73PQE5_0.S0 dvss.t303 ppolyf_u r_width=1u r_length=15u
X131 x1.nfet_03v3_EV2W8D_0.S1.t15 ibias1_250n x1.xamp.pfet_03v3_EQVFPB_0.S1_0 dvdd.t253 pfet_03v3 ad=0.86765p pd=4.88u as=0.86765p ps=4.88u w=2u l=0.5u
X132 dvdd.t213 a_n8227_n15930# x1.gf180mcu_as_sc_mcu7t3v3__buff_2_15.Y dvdd.t212 pfet_03v3 ad=0.3588p pd=1.9u as=0.3588p ps=1.9u w=1.38u l=0.28u
X133 dvss.t145 dvss.t145 dvss.t145 dvss.t71 nfet_03v3 ad=0.44p pd=2.88u as=0 ps=0 w=1u l=1u
X134 gf180mcu_ocd_ip__classab_buffer_0.se_folded_cascode_np_ab_0.pfet_03v3_9TM96F_0.G0_0 gf180mcu_ocd_ip__classab_buffer_0.se_folded_cascode_np_ab_0.pfet_03v3_9TM96F_0.G0_0 gf180mcu_ocd_ip__classab_buffer_0.se_folded_cascode_np_ab_0.outa1n.t4 dvdd.t19 pfet_03v3 ad=0.44p pd=2.88u as=0.44p ps=2.88u w=1u l=4u
X135 dvdd.t1 a_n8227_n24218# x1.gf180mcu_as_sc_mcu7t3v3__buff_2_6.Y dvdd.t119 pfet_03v3 ad=0.3588p pd=1.9u as=0.3588p ps=1.9u w=1.38u l=0.28u
X136 dvss.t257 a_n8227_n26906# x1.gf180mcu_as_sc_mcu7t3v3__buff_2_3.Y dvss.t260 nfet_03v3 ad=0.26p pd=1.52u as=0.26p ps=1.52u w=1u l=0.28u
X137 gf180mcu_ocd_ip__classab_buffer_0.se_folded_cascode_np_ab_0.nfet_03v3_XHQ8ZW_0.S0_0 x1.vbg gf180mcu_ocd_ip__classab_buffer_0.se_folded_cascode_np_ab_0.outa1p.t26 dvss.t71 nfet_03v3 ad=0.88p pd=4.88u as=0.88p ps=4.88u w=2u l=1u
X138 x1.gf180mcu_as_sc_mcu7t3v3__buff_2_3.Y a_n8227_n26906# dvdd.t131 dvdd.t134 pfet_03v3 ad=0.3588p pd=1.9u as=1.0488p ps=4.28u w=1.38u l=0.28u
X139 ibias1_250n ibias1_250n x1.xamp.vbp1.t13 dvdd.t250 pfet_03v3 ad=0.86765p pd=4.88u as=0.86765p ps=4.88u w=2u l=0.5u
X140 x1.xtr.nfet_03v3_GP977X_0.S7 x1.xtr.nfet_03v3_GP977X_0.S8 dvss.t32 ppolyf_u r_width=1u r_length=2.63u
X141 gf180mcu_ocd_ip__classab_buffer_0.se_folded_cascode_np_ab_0.outb1n gf180mcu_ocd_ip__classab_buffer_0.se_folded_cascode_np_ab_0.vbn1 dvss.t192 dvss.t201 nfet_03v3 ad=0.44p pd=2.88u as=0.44p ps=2.88u w=1u l=1u
X142 dvss.t24 dvss.t24 x1.pnp_05p00x05p00_0_0[0|0].E pnp_05p00x05p00
**devattr s=1000000,4000 d=225453094,146072
X143 x1.xamp.vbn2 x1.xamp.vbp1.t34 dvdd.t89 dvdd.t69 pfet_03v3 ad=0.44p pd=2.88u as=0.44p ps=2.88u w=1u l=1u
X144 x1.xamp.pfet_03v3_EQVFPB_0.G1_0.t14 ibias1_250n x1.xamp.pfet_03v3_EQVFPB_0.S1_1 dvdd.t253 pfet_03v3 ad=0.86765p pd=4.88u as=0.86765p ps=4.88u w=2u l=0.5u
X145 gf180mcu_ocd_ip__classab_buffer_0.se_folded_cascode_np_ab_0.outb1p gf180mcu_ocd_ip__classab_buffer_0.se_folded_cascode_np_ab_0.vbn1 dvss.t180 dvss.t209 nfet_03v3 ad=0.44p pd=2.88u as=0.44p ps=2.88u w=1u l=1u
X146 x1.xtr.nfet_03v3_GP977X_0.S10 x1.xtr.nfet_03v3_GP977X_0.S11 dvss.t28 ppolyf_u r_width=1u r_length=2.63u
X147 x1.xtr.nfet_03v3_GP977X_0.S13 x1.xtr.nfet_03v3_GP977X_0.S14 dvss.t36 ppolyf_u r_width=1u r_length=2.63u
X148 x1.xtr.nfet_03v3_GP977X_0.S13 x1.xtr.nfet_03v3_GP977X_0.S14 dvss.t36 ppolyf_u r_width=1u r_length=2.63u
X149 gf180mcu_ocd_ip__classab_buffer_0.se_folded_cascode_np_ab_0.outa1n.t37 gf180mcu_ocd_ip__classab_buffer_0.se_folded_cascode_np_ab_0.outa1n.t36 dvdd.t14 dvdd.t285 pfet_03v3 ad=0.44p pd=2.88u as=0.44p ps=2.88u w=1u l=1u
X150 gf180mcu_ocd_ip__classab_buffer_0.se_folded_cascode_np_ab_0.vbn2 gf180mcu_ocd_ip__classab_buffer_0.se_folded_cascode_np_ab_0.vbn2 gf180mcu_ocd_ip__classab_buffer_0.se_folded_cascode_np_ab_0.vbn1 dvss.t395 nfet_03v3 ad=0.88p pd=4.88u as=0.88p ps=4.88u w=2u l=4u
X151 x1.xamp.pfet_03v3_EQVFPB_0.G1_0.t1 x1.xamp.vbn2 x1.xamp.out1n dvss.t319 nfet_03v3 ad=0.43415p pd=2.88u as=0.43415p ps=2.88u w=1u l=4u
X152 dvdd.t295 x1.xamp.pfet_03v3_EQVFPB_0.G1_0.t37 x1.xamp.pfet_03v3_EQVFPB_0.S1_0 dvdd.t37 pfet_03v3 ad=0.87415p pd=4.88u as=0.87415p ps=4.88u w=2u l=4u
X153 gf180mcu_ocd_ip__classab_buffer_0.se_folded_cascode_np_ab_0.outb1p gf180mcu_ocd_ip__classab_buffer_0.se_folded_cascode_np_ab_0.vbn1 dvss.t192 dvss.t202 nfet_03v3 ad=0.44p pd=2.88u as=0.44p ps=2.88u w=1u l=1u
X154 x1.xamp.vbn1 x1.xamp.vbn1 dvss.t79 dvss.t357 nfet_03v3 ad=0.43415p pd=2.88u as=0.43415p ps=2.88u w=1u l=1u
X155 dvss.t10 a_n8227_n21306# x1.gf180mcu_as_sc_mcu7t3v3__buff_2_9.Y dvss.t9 nfet_03v3 ad=0.26p pd=1.52u as=0.26p ps=1.52u w=1u l=0.28u
X156 gf180mcu_ocd_ip__classab_buffer_0.se_folded_cascode_np_ab_0.vbn2 gf180mcu_ocd_ip__classab_buffer_0.se_folded_cascode_np_ab_0.vbp1 dvdd.t51 dvdd.t60 pfet_03v3 ad=0.44p pd=2.88u as=0.44p ps=2.88u w=1u l=1u
X157 x1.xamp.out1n x1.xamp.vbn1 dvss.t112 dvss.t354 nfet_03v3 ad=0.43415p pd=2.88u as=0.43415p ps=2.88u w=1u l=1u
X158 gf180mcu_ocd_ip__classab_buffer_0.se_folded_cascode_np_ab_0.vbp1 gf180mcu_ocd_ip__classab_buffer_0.se_folded_cascode_np_ab_0.vbp1 dvdd.t56 dvdd.t55 pfet_03v3 ad=0.44p pd=2.88u as=0.44p ps=2.88u w=1u l=1u
X159 x1.gf180mcu_as_sc_mcu7t3v3__buff_2_9.Y a_n8227_n21306# dvdd.t7 dvdd.t8 pfet_03v3 ad=0.3588p pd=1.9u as=1.0488p ps=4.28u w=1.38u l=0.28u
X160 gf180mcu_ocd_ip__classab_buffer_0.se_folded_cascode_np_ab_0.diffb x1.vbg gf180mcu_ocd_ip__classab_buffer_0.se_folded_cascode_np_ab_0.outb1p dvdd.t103 pfet_03v3 ad=1.76p pd=8.88u as=1.76p ps=8.88u w=4u l=1u
X161 x1.xtr.nfet_03v3_GP977X_0.S11 x1.xtr.nfet_03v3_GP977X_0.S12 dvss.t20 ppolyf_u r_width=1u r_length=2.63u
X162 x1.xtr.nfet_03v3_GP977X_0.S14 x1.xtr.nfet_03v3_GP977X_0.S15 dvss.t17 ppolyf_u r_width=1u r_length=2.63u
X163 x1.xtr.nfet_03v3_GP977X_0.S14 x1.xtr.nfet_03v3_GP977X_0.S15 dvss.t17 ppolyf_u r_width=1u r_length=2.63u
X164 gf180mcu_ocd_ip__classab_buffer_0.se_folded_cascode_np_ab_0.outb1p gf180mcu_ocd_ip__classab_buffer_0.se_folded_cascode_np_ab_0.vbn1 dvss.t171 dvss.t198 nfet_03v3 ad=0.44p pd=2.88u as=0.44p ps=2.88u w=1u l=1u
X165 x1.ena_buf a_n8227_n15034# dvdd.t213 dvdd.t221 pfet_03v3 ad=0.3588p pd=1.9u as=1.0488p ps=4.28u w=1.38u l=0.28u
X166 x1.gf180mcu_as_sc_mcu7t3v3__buff_2_13.Y a_n8227_n17722# dvss.t291 dvss.t292 nfet_03v3 ad=0.26p pd=1.52u as=0.76p ps=3.52u w=1u l=0.28u
X167 dvss.t111 dvss.t79 dvss.t110 dvss.t106 nfet_03v3 ad=0.43415p pd=2.88u as=0 ps=0 w=1u l=1u
X168 gf180mcu_ocd_ip__classab_buffer_0.se_folded_cascode_np_ab_0.nfet_03v3_XHQ8ZW_0.S0_0 vbg gf180mcu_ocd_ip__classab_buffer_0.se_folded_cascode_np_ab_0.outa1n.t45 dvss.t69 nfet_03v3 ad=0.88p pd=4.88u as=0.88p ps=4.88u w=2u l=1u
X169 x1.xamp.pfet_03v3_VL4T3E_0.S1_0 x1.xamp.vbp1.t27 dvdd.t70 dvdd.t69 pfet_03v3 ad=0.44p pd=2.88u as=0.44p ps=2.88u w=1u l=1u
X170 x1.xtr.top x1.xtr.nfet_03v3_GP977X_0.S1 dvss.t57 ppolyf_u r_width=1u r_length=2.63u
X171 x1.xamp.out1p x1.pnp_05p00x05p00_0_0[1|1].E x1.xamp.pfet_03v3_VL4T3E_0.S1_0 dvdd.t36 pfet_03v3 ad=1.76p pd=8.88u as=1.76p ps=8.88u w=4u l=1u
X172 gf180mcu_ocd_ip__classab_buffer_0.se_folded_cascode_np_ab_0.pfet_03v3_9TM96F_0.G0_0 gf180mcu_ocd_ip__classab_buffer_0.se_folded_cascode_np_ab_0.pfet_03v3_9TM96F_0.G0_0 gf180mcu_ocd_ip__classab_buffer_0.se_folded_cascode_np_ab_0.outa1n.t12 dvdd.t19 pfet_03v3 ad=0.44p pd=2.88u as=0.44p ps=2.88u w=1u l=4u
X173 dvss.t291 a_n8227_n18618# x1.gf180mcu_as_sc_mcu7t3v3__buff_2_12.Y dvss.t300 nfet_03v3 ad=0.26p pd=1.52u as=0.26p ps=1.52u w=1u l=0.28u
X174 x1.xtr.top x1.xtr.nfet_03v3_GP977X_0.S1 dvss.t57 ppolyf_u r_width=1u r_length=2.63u
X175 x1.xamp.pfet_03v3_VL4T3E_0.S1_0 x1.xamp.vbp1.t22 dvdd.t70 dvdd.t69 pfet_03v3 ad=0.44p pd=2.88u as=0.44p ps=2.88u w=1u l=1u
X176 x1.gf180mcu_as_sc_mcu7t3v3__buff_2_12.Y a_n8227_n18618# dvdd.t76 dvdd.t230 pfet_03v3 ad=0.3588p pd=1.9u as=1.0488p ps=4.28u w=1.38u l=0.28u
X177 x1.xtr.nfet_03v3_GP977X_0.S9 x1.gf180mcu_as_sc_mcu7t3v3__buff_2_6.Y x1.pnp_05p00x05p00_0_0[0|0].E.t20 dvss.t3 nfet_03v3 ad=1.2964p pd=7.08u as=1.2964p ps=7.08u w=3.1u l=0.28u
X178 x1.xamp.pfet_03v3_VL4T3E_0.S1_0 x1.xamp.vbp1.t17 dvdd.t70 dvdd.t69 pfet_03v3 ad=0.44p pd=2.88u as=0.44p ps=2.88u w=1u l=1u
X179 x1.xtr.nfet_03v3_GP977X_0.S9 x1.xtr.nfet_03v3_GP977X_0.S10 dvss.t3 ppolyf_u r_width=1u r_length=2.63u
X180 x1.xamp.out1n x1.xamp.vbn1 dvss.t112 dvss.t368 nfet_03v3 ad=0.43415p pd=2.88u as=0.43415p ps=2.88u w=1u l=1u
X181 ibias1_250n ibias1_250n x1.xamp.vbp1.t15 dvdd.t252 pfet_03v3 ad=0.86765p pd=4.88u as=0.86765p ps=4.88u w=2u l=0.5u
X182 x1.xtr.nfet_03v3_GP977X_0.S6 x1.gf180mcu_as_sc_mcu7t3v3__buff_2_9.Y x1.pnp_05p00x05p00_0_0[0|0].E.t2 dvss.t8 nfet_03v3 ad=1.2964p pd=7.08u as=1.2964p ps=7.08u w=3.1u l=0.28u
X183 x1.xtr.nfet_03v3_GP977X_0.S12 x1.xtr.nfet_03v3_GP977X_0.S13 dvss.t41 ppolyf_u r_width=1u r_length=2.63u
X184 gf180mcu_ocd_ip__classab_buffer_0.se_folded_cascode_np_ab_0.outb1p gf180mcu_ocd_ip__classab_buffer_0.se_folded_cascode_np_ab_0.vbn1 dvss.t180 dvss.t208 nfet_03v3 ad=0.44p pd=2.88u as=0.44p ps=2.88u w=1u l=1u
X185 gf180mcu_ocd_ip__classab_buffer_0.se_folded_cascode_np_ab_0.outb1p gf180mcu_ocd_ip__classab_buffer_0.se_folded_cascode_np_ab_0.vbn1 dvss.t180 dvss.t217 nfet_03v3 ad=0.44p pd=2.88u as=0.44p ps=2.88u w=1u l=1u
X186 x1.xamp.out1p x1.xamp.vbn1 dvss.t112 dvss.t355 nfet_03v3 ad=0.43415p pd=2.88u as=0.43415p ps=2.88u w=1u l=1u
X187 x1.xamp.out1p x1.xamp.vbn1 dvss.t83 dvss.t378 nfet_03v3 ad=0.43415p pd=2.88u as=0.43415p ps=2.88u w=1u l=1u
X188 gf180mcu_ocd_ip__classab_buffer_0.se_folded_cascode_np_ab_0.diffb gf180mcu_ocd_ip__classab_buffer_0.se_folded_cascode_np_ab_0.vbp1 dvdd.t42 dvdd.t43 pfet_03v3 ad=0.44p pd=2.88u as=0.44p ps=2.88u w=1u l=1u
X189 a_n8227_n16826# trim[14] dvdd.t223 dvdd.t275 pfet_03v3 ad=0.6072p pd=3.64u as=0.3588p ps=1.9u w=1.38u l=0.28u
X190 dvss.t105 dvss.t79 dvss.t104 dvss.t80 nfet_03v3 ad=0.43415p pd=2.88u as=0 ps=0 w=1u l=1u
X191 gf180mcu_ocd_ip__classab_buffer_0.se_folded_cascode_np_ab_0.vbn2 gf180mcu_ocd_ip__classab_buffer_0.se_folded_cascode_np_ab_0.vbn2 gf180mcu_ocd_ip__classab_buffer_0.se_folded_cascode_np_ab_0.vbn1 dvss.t395 nfet_03v3 ad=0.88p pd=4.88u as=0.88p ps=4.88u w=2u l=4u
X192 gf180mcu_ocd_ip__classab_buffer_0.se_folded_cascode_np_ab_0.outb1p gf180mcu_ocd_ip__classab_buffer_0.se_folded_cascode_np_ab_0.vbn1 dvss.t192 dvss.t200 nfet_03v3 ad=0.44p pd=2.88u as=0.44p ps=2.88u w=1u l=1u
X193 x1.xtr.nfet_03v3_GP977X_0.S1 x1.xtr.nfet_03v3_GP977X_0.S2 dvss.t76 ppolyf_u r_width=1u r_length=2.63u
X194 x1.xamp.out1n x1.xamp.vbn1 dvss.t83 dvss.t382 nfet_03v3 ad=0.43415p pd=2.88u as=0.43415p ps=2.88u w=1u l=1u
X195 gf180mcu_ocd_ip__classab_buffer_0.se_folded_cascode_np_ab_0.nfet_03v3_XRMCLC_0.S0_0 gf180mcu_ocd_ip__classab_buffer_0.se_folded_cascode_np_ab_0.pfet_03v3_XWLNX2_0.D.t41 vbg dvss.t66 nfet_03v3 ad=1.76p pd=8.88u as=1.76p ps=8.88u w=4u l=4u
X196 x1.xtr.nfet_03v3_GP977X_0.S1 x1.xtr.nfet_03v3_GP977X_0.S2 dvss.t76 ppolyf_u r_width=1u r_length=2.63u
X197 dvss.t124 dvss.t112 dvss.t123 dvss.t119 nfet_03v3 ad=0.43415p pd=2.88u as=0 ps=0 w=1u l=1u
X198 gf180mcu_ocd_ip__classab_buffer_0.se_folded_cascode_np_ab_0.outb1n gf180mcu_ocd_ip__classab_buffer_0.se_folded_cascode_np_ab_0.vbn1 dvss.t180 dvss.t193 nfet_03v3 ad=0.44p pd=2.88u as=0.44p ps=2.88u w=1u l=1u
X199 dvdd.t70 dvdd.t70 dvdd.t70 dvdd.t34 pfet_03v3 ad=1.76p pd=8.88u as=0 ps=0 w=4u l=1u
X200 x1.nfet_03v3_EV2W8D_0.S1.t18 ibias1_250n x1.xamp.pfet_03v3_EQVFPB_0.S1_0 dvdd.t253 pfet_03v3 ad=0.86765p pd=4.88u as=0.86765p ps=4.88u w=2u l=0.5u
X201 x1.xamp.out1n x1.xamp.vbn1 dvss.t112 dvss.t366 nfet_03v3 ad=0.43415p pd=2.88u as=0.43415p ps=2.88u w=1u l=1u
X202 x1.xtr.nfet_03v3_GP977X_0.S2 x1.xtr.nfet_03v3_GP977X_0.S3 dvss.t255 ppolyf_u r_width=1u r_length=2.63u
X203 dvss.t145 dvss.t145 dvss.t145 dvss.t69 nfet_03v3 ad=0.44p pd=2.88u as=0 ps=0 w=1u l=1u
X204 dvss.t242 a_n8227_n26010# x1.gf180mcu_as_sc_mcu7t3v3__buff_2_4.Y dvss.t310 nfet_03v3 ad=0.26p pd=1.52u as=0.26p ps=1.52u w=1u l=0.28u
X205 dvss.t24 dvss.t25 dvss.t23 ppolyf_u r_width=1u r_length=2.63u
X206 dvss.t24 dvss.t347 dvss.t23 ppolyf_u r_width=1u r_length=2.63u
X207 x1.xamp.out1n x1.xamp.vbn1 dvss.t83 dvss.t376 nfet_03v3 ad=0.43415p pd=2.88u as=0.43415p ps=2.88u w=1u l=1u
X208 x1.xamp.pfet_03v3_EQVFPB_0.G1_0.t6 x1.xamp.vbn2 x1.xamp.out1n dvss.t323 nfet_03v3 ad=0.43415p pd=2.88u as=0.43415p ps=2.88u w=1u l=4u
X209 dvss.t279 x1.ena_buf gf180mcu_ocd_ip__classab_buffer_0.se_folded_cascode_np_ab_0.nfet_03v3_XRMCLC_0.S0_0 dvss.t282 nfet_03v3 ad=1.73465p pd=8.88u as=1.73465p ps=8.88u w=4u l=0.28u
X210 dvdd.t168 dvdd.t183 dvdd.t168 dvdd.t167 pfet_03v3 ad=0.44p pd=2.88u as=0 ps=0 w=1u l=4u
X211 a_n3700_n16199# x1.xamp.inp dvss.t47 ppolyf_u r_width=1u r_length=15u
X212 gf180mcu_ocd_ip__classab_buffer_0.se_folded_cascode_np_ab_0.nfet_03v3_XHQ8ZW_0.S0_0 x1.vbg gf180mcu_ocd_ip__classab_buffer_0.se_folded_cascode_np_ab_0.outa1p.t24 dvss.t69 nfet_03v3 ad=0.88p pd=4.88u as=0.88p ps=4.88u w=2u l=1u
X213 x1.xtr.nfet_03v3_GP977X_0.S8 x1.xtr.nfet_03v3_GP977X_0.S9 dvss.t1 ppolyf_u r_width=1u r_length=2.63u
X214 dvdd.t210 x1.pfet_03v3_BWTVHK_0.D x1.pfet_03v3_BWTVHK_0.D dvdd.t209 pfet_03v3 ad=0.44p pd=2.88u as=0.44p ps=2.88u w=1u l=1u
X215 gf180mcu_ocd_ip__classab_buffer_0.se_folded_cascode_np_ab_0.outa1n.t19 gf180mcu_ocd_ip__classab_buffer_0.se_folded_cascode_np_ab_0.outa1n.t18 dvdd.t12 dvdd.t11 pfet_03v3 ad=0.44p pd=2.88u as=0.44p ps=2.88u w=1u l=1u
X216 gf180mcu_ocd_ip__classab_buffer_0.se_folded_cascode_np_ab_0.vbp1 gf180mcu_ocd_ip__classab_buffer_0.se_folded_cascode_np_ab_0.vbp1 dvdd.t51 dvdd.t58 pfet_03v3 ad=0.44p pd=2.88u as=0.44p ps=2.88u w=1u l=1u
X217 dvdd.t219 x1.ena_buf gf180mcu_ocd_ip__classab_buffer_0.se_folded_cascode_np_ab_0.pfet_03v3_XWLNX2_0.D.t21 dvdd.t218 pfet_03v3 ad=0.4231p pd=2.88u as=0.4231p ps=2.88u w=1u l=0.28u
X218 x1.nfet_03v3_EV2W8D_0.S1.t20 ibias1_250n x1.xamp.pfet_03v3_EQVFPB_0.S1_0 dvdd.t253 pfet_03v3 ad=0.86765p pd=4.88u as=0.86765p ps=4.88u w=2u l=0.5u
X219 x1.xamp.out1n x1.xamp.vbn1 dvss.t112 dvss.t356 nfet_03v3 ad=0.43415p pd=2.88u as=0.43415p ps=2.88u w=1u l=1u
X220 dvdd.t32 gf180mcu_ocd_ip__classab_buffer_0.se_folded_cascode_np_ab_0.pfet_03v3_XWLNX2_0.D.t45 vbg dvdd.t31 pfet_03v3 ad=1.76p pd=8.88u as=1.76p ps=8.88u w=4u l=4u
X221 x1.nfet_03v3_EV2W8D_0.S1.t16 ibias1_250n x1.xamp.pfet_03v3_EQVFPB_0.S1_0 dvdd.t253 pfet_03v3 ad=0.86765p pd=4.88u as=0.86765p ps=4.88u w=2u l=0.5u
X222 gf180mcu_ocd_ip__classab_buffer_0.se_folded_cascode_np_ab_0.outb1n gf180mcu_ocd_ip__classab_buffer_0.se_folded_cascode_np_ab_0.vbn1 dvss.t171 dvss.t181 nfet_03v3 ad=0.44p pd=2.88u as=0.44p ps=2.88u w=1u l=1u
X223 gf180mcu_ocd_ip__classab_buffer_0.se_folded_cascode_np_ab_0.nfet_03v3_XHQ8ZW_0.S0_0 vbg gf180mcu_ocd_ip__classab_buffer_0.se_folded_cascode_np_ab_0.outa1n.t46 dvss.t70 nfet_03v3 ad=0.88p pd=4.88u as=0.88p ps=4.88u w=2u l=1u
X224 dvdd.t160 dvdd.t161 dvdd.t163 dvdd.t162 pfet_03v3 ad=0.4257p pd=2.88u as=0 ps=0 w=1u l=0.5u
X225 gf180mcu_ocd_ip__classab_buffer_0.se_folded_cascode_np_ab_0.outb1n gf180mcu_ocd_ip__classab_buffer_0.se_folded_cascode_np_ab_0.vbn1 dvss.t180 dvss.t210 nfet_03v3 ad=0.44p pd=2.88u as=0.44p ps=2.88u w=1u l=1u
X226 x1.xamp.pfet_03v3_EQVFPB_0.G1_0.t12 ibias1_250n x1.xamp.pfet_03v3_EQVFPB_0.S1_1 dvdd.t253 pfet_03v3 ad=0.86765p pd=4.88u as=0.86765p ps=4.88u w=2u l=0.5u
X227 gf180mcu_ocd_ip__classab_buffer_0.se_folded_cascode_np_ab_0.vbn2 gf180mcu_ocd_ip__classab_buffer_0.se_folded_cascode_np_ab_0.vbn2 gf180mcu_ocd_ip__classab_buffer_0.se_folded_cascode_np_ab_0.vbn1 dvss.t395 nfet_03v3 ad=0.88p pd=4.88u as=0.88p ps=4.88u w=2u l=4u
X228 x1.xamp.pfet_03v3_EQVFPB_0.G1_0.t8 ibias1_250n x1.xamp.pfet_03v3_EQVFPB_0.S1_1 dvdd.t253 pfet_03v3 ad=0.86765p pd=4.88u as=0.86765p ps=4.88u w=2u l=0.5u
X229 dvss.t14 a_n8227_n20410# x1.gf180mcu_as_sc_mcu7t3v3__buff_2_10.Y dvss.t13 nfet_03v3 ad=0.26p pd=1.52u as=0.26p ps=1.52u w=1u l=0.28u
X230 x1.xtr.nfet_03v3_GP977X_0.S3 x1.xtr.nfet_03v3_GP977X_0.S4 dvss.t27 ppolyf_u r_width=1u r_length=2.63u
X231 x1.xtr.nfet_03v3_GP977X_0.S3 x1.xtr.nfet_03v3_GP977X_0.S4 dvss.t27 ppolyf_u r_width=1u r_length=2.63u
X232 dvdd.t160 dvdd.t158 dvdd.t160 dvdd.t159 pfet_03v3 ad=0.4257p pd=2.88u as=0 ps=0 w=1u l=0.5u
X233 gf180mcu_ocd_ip__classab_buffer_0.se_folded_cascode_np_ab_0.vbp1 ibias2_1u ibias2_1u dvdd.t141 pfet_03v3 ad=0.4257p pd=2.88u as=0.4257p ps=2.88u w=1u l=0.5u
X234 gf180mcu_ocd_ip__classab_buffer_0.se_folded_cascode_np_ab_0.pfet_03v3_9TM96F_0.G0_0 gf180mcu_ocd_ip__classab_buffer_0.se_folded_cascode_np_ab_0.pfet_03v3_9TM96F_0.G0_0 gf180mcu_ocd_ip__classab_buffer_0.se_folded_cascode_np_ab_0.outa1n.t10 dvdd.t22 pfet_03v3 ad=0.44p pd=2.88u as=0.44p ps=2.88u w=1u l=4u
X235 gf180mcu_ocd_ip__classab_buffer_0.se_folded_cascode_np_ab_0.outa1p.t1 gf180mcu_ocd_ip__classab_buffer_0.se_folded_cascode_np_ab_0.outa1n.t57 dvdd.t16 dvdd.t15 pfet_03v3 ad=0.44p pd=2.88u as=0.44p ps=2.88u w=1u l=1u
X236 gf180mcu_ocd_ip__classab_buffer_0.se_folded_cascode_np_ab_0.outb1n gf180mcu_ocd_ip__classab_buffer_0.se_folded_cascode_np_ab_0.vbn1 dvss.t180 dvss.t218 nfet_03v3 ad=0.44p pd=2.88u as=0.44p ps=2.88u w=1u l=1u
X237 gf180mcu_ocd_ip__classab_buffer_0.se_folded_cascode_np_ab_0.diffb x1.vbg gf180mcu_ocd_ip__classab_buffer_0.se_folded_cascode_np_ab_0.outb1p dvdd.t101 pfet_03v3 ad=1.76p pd=8.88u as=1.76p ps=8.88u w=4u l=1u
X238 gf180mcu_ocd_ip__classab_buffer_0.se_folded_cascode_np_ab_0.diffb gf180mcu_ocd_ip__classab_buffer_0.se_folded_cascode_np_ab_0.vbp1 dvdd.t42 dvdd.t41 pfet_03v3 ad=0.44p pd=2.88u as=0.44p ps=2.88u w=1u l=1u
X239 x1.gf180mcu_as_sc_mcu7t3v3__buff_2_10.Y a_n8227_n20410# dvdd.t7 dvdd.t10 pfet_03v3 ad=0.3588p pd=1.9u as=1.0488p ps=4.28u w=1.38u l=0.28u
X240 gf180mcu_ocd_ip__classab_buffer_0.se_folded_cascode_np_ab_0.outb1n gf180mcu_ocd_ip__classab_buffer_0.se_folded_cascode_np_ab_0.vbn2 gf180mcu_ocd_ip__classab_buffer_0.se_folded_cascode_np_ab_0.pfet_03v3_9TM96F_0.G0_0 dvss.t403 nfet_03v3 ad=0.88p pd=4.88u as=0.88p ps=4.88u w=2u l=4u
X241 dvss.t394 gf180mcu_ocd_ip__classab_buffer_0.se_folded_cascode_np_ab_0.vbn2 dvss.t394 dvss.t393 nfet_03v3 ad=0.88p pd=4.88u as=0 ps=0 w=2u l=4u
X242 x1.gf180mcu_as_sc_mcu7t3v3__buff_2_14.Y a_n8227_n16826# dvss.t276 dvss.t295 nfet_03v3 ad=0.26p pd=1.52u as=0.76p ps=3.52u w=1u l=0.28u
X243 x1.gf180mcu_as_sc_mcu7t3v3__buff_2_5.Y a_n8227_n25114# dvss.t242 dvss.t243 nfet_03v3 ad=0.26p pd=1.52u as=0.76p ps=3.52u w=1u l=0.28u
X244 a_n3700_n17319# a_n598_n16759# dvss.t350 ppolyf_u r_width=1u r_length=15u
X245 x1.xtr.nfet_03v3_GP977X_0.S4 x1.xtr.nfet_03v3_GP977X_0.S5 dvss.t19 ppolyf_u r_width=1u r_length=2.63u
X246 dvdd.t294 x1.xamp.pfet_03v3_EQVFPB_0.G1_0.t36 x1.xamp.pfet_03v3_EQVFPB_0.S1_1 dvdd.t77 pfet_03v3 ad=0.87415p pd=4.88u as=0.87415p ps=4.88u w=2u l=4u
X247 x1.xamp.pfet_03v3_EQVFPB_0.G1_0.t10 ibias1_250n x1.xamp.pfet_03v3_EQVFPB_0.S1_1 dvdd.t253 pfet_03v3 ad=0.86765p pd=4.88u as=0.86765p ps=4.88u w=2u l=0.5u
X248 a_n8227_n15034# ena dvss.t288 dvss.t341 nfet_03v3 ad=0.44p pd=2.88u as=0.26p ps=1.52u w=1u l=0.28u
X249 x1.xtr.nfet_03v3_GP977X_0.S4 x1.xtr.nfet_03v3_GP977X_0.S5 dvss.t19 ppolyf_u r_width=1u r_length=2.63u
X250 x1.xamp.vbn1 x1.xamp.vbn2 x1.xamp.vbn2 dvss.t317 nfet_03v3 ad=0.43415p pd=2.88u as=0.43415p ps=2.88u w=1u l=4u
X251 a_n8227_n23322# trim[7] dvss.t2 dvss.t315 nfet_03v3 ad=0.44p pd=2.88u as=0.26p ps=1.52u w=1u l=0.28u
X252 x1.xtr.nfet_03v3_GP977X_0.S10 x1.xtr.nfet_03v3_GP977X_0.S11 dvss.t28 ppolyf_u r_width=1u r_length=2.63u
X253 x1.xtr.nfet_03v3_GP977X_0.S13 x1.xtr.nfet_03v3_GP977X_0.S14 dvss.t36 ppolyf_u r_width=1u r_length=2.63u
X254 gf180mcu_ocd_ip__classab_buffer_0.se_folded_cascode_np_ab_0.outa1p.t31 gf180mcu_ocd_ip__classab_buffer_0.se_folded_cascode_np_ab_0.outa1n.t52 dvdd.t14 dvdd.t282 pfet_03v3 ad=0.44p pd=2.88u as=0.44p ps=2.88u w=1u l=1u
X255 gf180mcu_ocd_ip__classab_buffer_0.se_folded_cascode_np_ab_0.outa1n.t27 gf180mcu_ocd_ip__classab_buffer_0.se_folded_cascode_np_ab_0.outa1n.t26 dvdd.t14 dvdd.t280 pfet_03v3 ad=0.44p pd=2.88u as=0.44p ps=2.88u w=1u l=1u
X256 dvss.t145 dvss.t145 dvss.t145 dvss.t70 nfet_03v3 ad=0.44p pd=2.88u as=0 ps=0 w=1u l=1u
X257 gf180mcu_ocd_ip__classab_buffer_0.se_folded_cascode_np_ab_0.nfet_03v3_XHQ8ZW_0.S0_0 gf180mcu_ocd_ip__classab_buffer_0.se_folded_cascode_np_ab_0.vbn1 dvss.t145 dvss.t72 nfet_03v3 ad=0.44p pd=2.88u as=0.44p ps=2.88u w=1u l=1u
X258 gf180mcu_ocd_ip__classab_buffer_0.se_folded_cascode_np_ab_0.nfet_03v3_XHQ8ZW_0.S0_0 x1.vbg gf180mcu_ocd_ip__classab_buffer_0.se_folded_cascode_np_ab_0.outa1p.t25 dvss.t70 nfet_03v3 ad=0.88p pd=4.88u as=0.88p ps=4.88u w=2u l=1u
X259 x1.gf180mcu_as_sc_mcu7t3v3__buff_2_4.Y a_n8227_n26010# dvdd.t117 dvdd.t235 pfet_03v3 ad=0.3588p pd=1.9u as=1.0488p ps=4.28u w=1.38u l=0.28u
X260 gf180mcu_ocd_ip__classab_buffer_0.se_folded_cascode_np_ab_0.outb1n gf180mcu_ocd_ip__classab_buffer_0.se_folded_cascode_np_ab_0.vbn2 gf180mcu_ocd_ip__classab_buffer_0.se_folded_cascode_np_ab_0.pfet_03v3_9TM96F_0.G0_0 dvss.t396 nfet_03v3 ad=0.88p pd=4.88u as=0.88p ps=4.88u w=2u l=4u
X261 x1.xamp.pfet_03v3_EQVFPB_0.G1_0.t4 x1.xamp.vbn2 x1.xamp.out1n dvss.t321 nfet_03v3 ad=0.43415p pd=2.88u as=0.43415p ps=2.88u w=1u l=4u
X262 gf180mcu_ocd_ip__classab_buffer_0.se_folded_cascode_np_ab_0.diffb gf180mcu_ocd_ip__classab_buffer_0.se_folded_cascode_np_ab_0.vbp1 dvdd.t42 dvdd.t46 pfet_03v3 ad=0.44p pd=2.88u as=0.44p ps=2.88u w=1u l=1u
X263 a_n8227_n15930# trim[15] dvdd.t213 dvdd.t266 pfet_03v3 ad=0.6072p pd=3.64u as=0.3588p ps=1.9u w=1.38u l=0.28u
X264 gf180mcu_ocd_ip__classab_buffer_0.se_folded_cascode_np_ab_0.outb1p gf180mcu_ocd_ip__classab_buffer_0.se_folded_cascode_np_ab_0.vbn1 dvss.t180 dvss.t216 nfet_03v3 ad=0.44p pd=2.88u as=0.44p ps=2.88u w=1u l=1u
X265 dvdd.t160 dvdd.t161 dvdd.t163 dvdd.t162 pfet_03v3 ad=0.4257p pd=2.88u as=0 ps=0 w=1u l=0.5u
X266 x1.nfet_03v3_EV2W8D_0.S0 x1.vbg dvss.t24 dvss.t67 nfet_03v3 ad=0.44p pd=2.88u as=0.44p ps=2.88u w=1u l=1u
X267 x1.xamp.out1n x1.xamp.vbn1 dvss.t63 dvss.t370 nfet_03v3 ad=0.43415p pd=2.88u as=0.43415p ps=2.88u w=1u l=1u
X268 x1.xtr.nfet_03v3_GP977X_0.S11 x1.xtr.nfet_03v3_GP977X_0.S12 dvss.t20 ppolyf_u r_width=1u r_length=2.63u
X269 gf180mcu_ocd_ip__classab_buffer_0.se_folded_cascode_np_ab_0.outb1n gf180mcu_ocd_ip__classab_buffer_0.se_folded_cascode_np_ab_0.vbn2 gf180mcu_ocd_ip__classab_buffer_0.se_folded_cascode_np_ab_0.pfet_03v3_9TM96F_0.G0_0 dvss.t399 nfet_03v3 ad=0.88p pd=4.88u as=0.88p ps=4.88u w=2u l=4u
X270 x1.xtr.nfet_03v3_GP977X_0.S14 x1.xtr.nfet_03v3_GP977X_0.S15 dvss.t17 ppolyf_u r_width=1u r_length=2.63u
X271 x1.xamp.out1p x1.xamp.vbn1 dvss.t83 dvss.t380 nfet_03v3 ad=0.43415p pd=2.88u as=0.43415p ps=2.88u w=1u l=1u
X272 x1.xamp.out1p x1.pnp_05p00x05p00_0_0[1|1].E x1.xamp.pfet_03v3_VL4T3E_0.S1_0 dvdd.t34 pfet_03v3 ad=1.76p pd=8.88u as=1.76p ps=8.88u w=4u l=1u
X273 x1.xtr.top x1.xtr.nfet_03v3_GP977X_0.S1 dvss.t57 ppolyf_u r_width=1u r_length=2.63u
X274 gf180mcu_ocd_ip__classab_buffer_0.se_folded_cascode_np_ab_0.outb1p gf180mcu_ocd_ip__classab_buffer_0.se_folded_cascode_np_ab_0.vbn1 dvss.t180 dvss.t211 nfet_03v3 ad=0.44p pd=2.88u as=0.44p ps=2.88u w=1u l=1u
X275 gf180mcu_ocd_ip__classab_buffer_0.se_folded_cascode_np_ab_0.vbp1 ibias2_1u ibias2_1u dvdd.t142 pfet_03v3 ad=0.4257p pd=2.88u as=0.4257p ps=2.88u w=1u l=0.5u
X276 x1.nfet_03v3_EV2W8D_0.S1.t23 ibias1_250n x1.xamp.pfet_03v3_EQVFPB_0.S1_0 dvdd.t253 pfet_03v3 ad=0.86765p pd=4.88u as=0.86765p ps=4.88u w=2u l=0.5u
X277 dvss.t394 gf180mcu_ocd_ip__classab_buffer_0.se_folded_cascode_np_ab_0.vbn2 dvss.t394 dvss.t393 nfet_03v3 ad=0.88p pd=4.88u as=0 ps=0 w=2u l=4u
X278 dvss.t24 dvss.t24 x1.pnp_05p00x05p00_0_0[0|0].E pnp_05p00x05p00
**devattr s=1000000,4000 d=225453094,146072
X279 x1.xtr.nfet_03v3_GP977X_0.S12 x1.xtr.nfet_03v3_GP977X_0.S13 dvss.t41 ppolyf_u r_width=1u r_length=2.63u
X280 a_n3700_n18439# a_n598_n17879# dvss.t26 ppolyf_u r_width=1u r_length=15u
X281 gf180mcu_ocd_ip__classab_buffer_0.se_folded_cascode_np_ab_0.outa1p.t20 gf180mcu_ocd_ip__classab_buffer_0.se_folded_cascode_np_ab_0.outa1n.t55 dvdd.t14 dvdd.t40 pfet_03v3 ad=0.44p pd=2.88u as=0.44p ps=2.88u w=1u l=1u
X282 gf180mcu_ocd_ip__classab_buffer_0.se_folded_cascode_np_ab_0.vbn2 gf180mcu_ocd_ip__classab_buffer_0.se_folded_cascode_np_ab_0.vbp1 dvdd.t51 dvdd.t59 pfet_03v3 ad=0.44p pd=2.88u as=0.44p ps=2.88u w=1u l=1u
X283 gf180mcu_ocd_ip__classab_buffer_0.se_folded_cascode_np_ab_0.diffb gf180mcu_ocd_ip__classab_buffer_0.se_folded_cascode_np_ab_0.vbp1 dvdd.t48 dvdd.t52 pfet_03v3 ad=0.44p pd=2.88u as=0.44p ps=2.88u w=1u l=1u
X284 x1.xamp.out1p x1.xamp.vbn1 dvss.t63 dvss.t372 nfet_03v3 ad=0.43415p pd=2.88u as=0.43415p ps=2.88u w=1u l=1u
X285 vbg gf180mcu_ocd_ip__classab_buffer_0.se_folded_cascode_np_ab_0.pfet_03v3_XWLNX2_0.D.t19 cap_mim_2f0_m4m5_noshield c_width=19u c_length=12u
X286 x1.xtr.nfet_03v3_GP977X_0.S1 x1.xtr.nfet_03v3_GP977X_0.S2 dvss.t76 ppolyf_u r_width=1u r_length=2.63u
X287 x1.xamp.out1n x1.xamp.vbn1 dvss.t83 dvss.t383 nfet_03v3 ad=0.43415p pd=2.88u as=0.43415p ps=2.88u w=1u l=1u
X288 gf180mcu_ocd_ip__classab_buffer_0.se_folded_cascode_np_ab_0.nfet_03v3_XHQ8ZW_0.S0_0 vbg gf180mcu_ocd_ip__classab_buffer_0.se_folded_cascode_np_ab_0.outa1n.t44 dvss.t68 nfet_03v3 ad=0.88p pd=4.88u as=0.88p ps=4.88u w=2u l=1u
X289 dvdd.t163 dvdd.t161 dvdd.t163 dvdd.t164 pfet_03v3 ad=0.4257p pd=2.88u as=0 ps=0 w=1u l=0.5u
X290 x1.nfet_03v3_EV2W8D_0.S1.t14 ibias1_250n x1.xamp.pfet_03v3_EQVFPB_0.S1_0 dvdd.t253 pfet_03v3 ad=0.86765p pd=4.88u as=0.86765p ps=4.88u w=2u l=0.5u
X291 gf180mcu_ocd_ip__classab_buffer_0.se_folded_cascode_np_ab_0.outb1p gf180mcu_ocd_ip__classab_buffer_0.se_folded_cascode_np_ab_0.vbn2 gf180mcu_ocd_ip__classab_buffer_0.se_folded_cascode_np_ab_0.pfet_03v3_XWLNX2_0.D.t30 dvss.t396 nfet_03v3 ad=0.88p pd=4.88u as=0.88p ps=4.88u w=2u l=4u
X292 x1.xamp.out1p x1.pnp_05p00x05p00_0_0[1|1].E x1.xamp.pfet_03v3_VL4T3E_0.S1_0 dvdd.t35 pfet_03v3 ad=1.76p pd=8.88u as=1.76p ps=8.88u w=4u l=1u
X293 x1.xtr.top x1.xtr.top dvss.t39 ppolyf_u r_width=1u r_length=2.63u
X294 dvss.t133 dvss.t128 dvss.t132 dvss.t125 nfet_03v3 ad=0.43415p pd=2.88u as=0 ps=0 w=1u l=1u
X295 x1.xtr.top x1.xtr.top dvss.t39 ppolyf_u r_width=1u r_length=2.63u
X296 gf180mcu_ocd_ip__classab_buffer_0.se_folded_cascode_np_ab_0.outa1p.t33 gf180mcu_ocd_ip__classab_buffer_0.se_folded_cascode_np_ab_0.outa1n.t50 dvdd.t14 dvdd.t286 pfet_03v3 ad=0.44p pd=2.88u as=0.44p ps=2.88u w=1u l=1u
X297 dvss.t24 dvss.t25 dvss.t23 ppolyf_u r_width=1u r_length=2.63u
X298 x1.xtr.nfet_03v3_GP977X_0.S5 x1.xtr.nfet_03v3_GP977X_0.S6 dvss.t40 ppolyf_u r_width=1u r_length=2.63u
X299 x1.xtr.nfet_03v3_GP977X_0.S5 x1.xtr.nfet_03v3_GP977X_0.S6 dvss.t40 ppolyf_u r_width=1u r_length=2.63u
X300 gf180mcu_ocd_ip__classab_buffer_0.se_folded_cascode_np_ab_0.outa1p.t9 gf180mcu_ocd_ip__classab_buffer_0.se_folded_cascode_np_ab_0.pfet_03v3_9TM96F_0.G0_0 gf180mcu_ocd_ip__classab_buffer_0.se_folded_cascode_np_ab_0.pfet_03v3_XWLNX2_0.D.t10 dvdd.t24 pfet_03v3 ad=0.44p pd=2.88u as=0.44p ps=2.88u w=1u l=4u
X301 gf180mcu_ocd_ip__classab_buffer_0.se_folded_cascode_np_ab_0.diffb vbg gf180mcu_ocd_ip__classab_buffer_0.se_folded_cascode_np_ab_0.outb1n dvdd.t99 pfet_03v3 ad=1.76p pd=8.88u as=1.76p ps=8.88u w=4u l=1u
X302 x1.xamp.pfet_03v3_EQVFPB_0.G1_0.t13 ibias1_250n x1.xamp.pfet_03v3_EQVFPB_0.S1_1 dvdd.t253 pfet_03v3 ad=0.86765p pd=4.88u as=0.86765p ps=4.88u w=2u l=0.5u
X303 gf180mcu_ocd_ip__classab_buffer_0.se_folded_cascode_np_ab_0.outb1n gf180mcu_ocd_ip__classab_buffer_0.se_folded_cascode_np_ab_0.vbn1 dvss.t180 dvss.t179 nfet_03v3 ad=0.44p pd=2.88u as=0.44p ps=2.88u w=1u l=1u
X304 dvdd.t70 dvdd.t70 dvdd.t70 dvdd.t33 pfet_03v3 ad=1.76p pd=8.88u as=0 ps=0 w=4u l=1u
X305 x1.gf180mcu_as_sc_mcu7t3v3__buff_2_15.Y a_n8227_n15930# dvss.t276 dvss.t277 nfet_03v3 ad=0.26p pd=1.52u as=0.76p ps=3.52u w=1u l=0.28u
X306 dvss.t127 dvss.t83 dvss.t126 dvss.t125 nfet_03v3 ad=0.43415p pd=2.88u as=0 ps=0 w=1u l=1u
X307 dvss.t394 gf180mcu_ocd_ip__classab_buffer_0.se_folded_cascode_np_ab_0.vbn2 dvss.t394 dvss.t393 nfet_03v3 ad=0.88p pd=4.88u as=0 ps=0 w=2u l=4u
X308 x1.gf180mcu_as_sc_mcu7t3v3__buff_2_6.Y a_n8227_n24218# dvss.t2 dvss.t245 nfet_03v3 ad=0.26p pd=1.52u as=0.76p ps=3.52u w=1u l=0.28u
X309 a_n3700_n19559# a_n598_n18999# dvss.t38 ppolyf_u r_width=1u r_length=15u
X310 a_n3700_n20679# a_n598_n21239# dvss.t412 ppolyf_u r_width=1u r_length=15u
X311 dvdd.t217 x1.ena_buf ibias1_250n dvdd.t216 pfet_03v3 ad=0.44p pd=2.88u as=0.44p ps=2.88u w=1u l=0.5u
X312 gf180mcu_ocd_ip__classab_buffer_0.se_folded_cascode_np_ab_0.outa1p.t6 gf180mcu_ocd_ip__classab_buffer_0.se_folded_cascode_np_ab_0.pfet_03v3_9TM96F_0.G0_0 gf180mcu_ocd_ip__classab_buffer_0.se_folded_cascode_np_ab_0.pfet_03v3_XWLNX2_0.D.t7 dvdd.t18 pfet_03v3 ad=0.44p pd=2.88u as=0.44p ps=2.88u w=1u l=4u
X313 x1.xtr.nfet_03v3_GP977X_0.S6 x1.xtr.nfet_03v3_GP977X_0.S7 dvss.t18 ppolyf_u r_width=1u r_length=2.63u
X314 dvdd.t113 gf180mcu_ocd_ip__classab_buffer_0.se_folded_cascode_np_ab_0.pfet_03v3_XWLNX2_0.D.t44 vbg dvdd.t86 pfet_03v3 ad=1.76p pd=8.88u as=1.76p ps=8.88u w=4u l=4u
X315 x1.xtr.nfet_03v3_GP977X_0.S6 x1.xtr.nfet_03v3_GP977X_0.S7 dvss.t18 ppolyf_u r_width=1u r_length=2.63u
X316 dvdd.t263 x1.xamp.pfet_03v3_EQVFPB_0.G1_0.t25 x1.xamp.pfet_03v3_EQVFPB_0.S1_0 dvdd.t37 pfet_03v3 ad=0.87415p pd=4.88u as=0.87415p ps=4.88u w=2u l=4u
X317 dvss.t24 dvss.t24 x1.pnp_05p00x05p00_0_0[0|0].E pnp_05p00x05p00
**devattr s=1000000,4000 d=225453094,146072
X318 dvdd.t107 x1.nfet_03v3_EV2W8D_0.S1.t26 x1.pfet_03v3_73PQE5_0.S0 dvdd.t259 pfet_03v3 ad=1.74765p pd=8.88u as=1.74765p ps=8.88u w=4u l=0.5u
X319 gf180mcu_ocd_ip__classab_buffer_0.se_folded_cascode_np_ab_0.outb1n gf180mcu_ocd_ip__classab_buffer_0.se_folded_cascode_np_ab_0.vbn1 dvss.t204 dvss.t205 nfet_03v3 ad=0.44p pd=2.88u as=0.44p ps=2.88u w=1u l=1u
X320 dvss.t145 dvss.t145 dvss.t145 dvss.t68 nfet_03v3 ad=0.44p pd=2.88u as=0 ps=0 w=1u l=1u
X321 gf180mcu_ocd_ip__classab_buffer_0.se_folded_cascode_np_ab_0.nfet_03v3_XHQ8ZW_0.S0_0 x1.vbg gf180mcu_ocd_ip__classab_buffer_0.se_folded_cascode_np_ab_0.outa1p.t23 dvss.t68 nfet_03v3 ad=0.88p pd=4.88u as=0.88p ps=4.88u w=2u l=1u
X322 x1.xtr.nfet_03v3_GP977X_0.S3 x1.xtr.nfet_03v3_GP977X_0.S4 dvss.t27 ppolyf_u r_width=1u r_length=2.63u
X323 gf180mcu_ocd_ip__classab_buffer_0.se_folded_cascode_np_ab_0.outb1n gf180mcu_ocd_ip__classab_buffer_0.se_folded_cascode_np_ab_0.vbn2 gf180mcu_ocd_ip__classab_buffer_0.se_folded_cascode_np_ab_0.pfet_03v3_9TM96F_0.G0_0 dvss.t396 nfet_03v3 ad=0.88p pd=4.88u as=0.88p ps=4.88u w=2u l=4u
X324 gf180mcu_ocd_ip__classab_buffer_0.se_folded_cascode_np_ab_0.outa1n.t17 gf180mcu_ocd_ip__classab_buffer_0.se_folded_cascode_np_ab_0.outa1n.t16 dvdd.t12 dvdd.t26 pfet_03v3 ad=0.44p pd=2.88u as=0.44p ps=2.88u w=1u l=1u
X325 gf180mcu_ocd_ip__classab_buffer_0.se_folded_cascode_np_ab_0.vbp1 gf180mcu_ocd_ip__classab_buffer_0.se_folded_cascode_np_ab_0.vbp1 dvdd.t51 dvdd.t50 pfet_03v3 ad=0.44p pd=2.88u as=0.44p ps=2.88u w=1u l=1u
X326 x1.nfet_03v3_EV2W8D_0.S1.t19 ibias1_250n x1.xamp.pfet_03v3_EQVFPB_0.S1_0 dvdd.t253 pfet_03v3 ad=0.86765p pd=4.88u as=0.86765p ps=4.88u w=2u l=0.5u
X327 a_n8227_n29594# trim[0] dvdd.t81 dvdd.t233 pfet_03v3 ad=0.6072p pd=3.64u as=0.3588p ps=1.9u w=1.38u l=0.28u
X328 dvdd.t163 dvdd.t161 dvdd.t163 dvdd.t164 pfet_03v3 ad=0.4257p pd=2.88u as=0 ps=0 w=1u l=0.5u
X329 gf180mcu_ocd_ip__classab_buffer_0.se_folded_cascode_np_ab_0.diffb x1.vbg gf180mcu_ocd_ip__classab_buffer_0.se_folded_cascode_np_ab_0.outb1p dvdd.t104 pfet_03v3 ad=1.76p pd=8.88u as=1.76p ps=8.88u w=4u l=1u
X330 x1.xamp.vbn2 x1.xamp.vbp1.t35 dvdd.t89 dvdd.t69 pfet_03v3 ad=0.44p pd=2.88u as=0.44p ps=2.88u w=1u l=1u
X331 gf180mcu_ocd_ip__classab_buffer_0.se_folded_cascode_np_ab_0.outa1p.t7 gf180mcu_ocd_ip__classab_buffer_0.se_folded_cascode_np_ab_0.pfet_03v3_9TM96F_0.G0_0 gf180mcu_ocd_ip__classab_buffer_0.se_folded_cascode_np_ab_0.pfet_03v3_XWLNX2_0.D.t15 dvdd.t20 pfet_03v3 ad=0.44p pd=2.88u as=0.44p ps=2.88u w=1u l=4u
X332 x1.xtr.nfet_03v3_GP977X_0.S7 x1.xtr.nfet_03v3_GP977X_0.S8 dvss.t32 ppolyf_u r_width=1u r_length=2.63u
X333 dvss.t279 x1.ena_buf gf180mcu_ocd_ip__classab_buffer_0.se_folded_cascode_np_ab_0.nfet_03v3_XRMCLC_0.S0_0 dvss.t281 nfet_03v3 ad=1.73465p pd=8.88u as=1.73465p ps=8.88u w=4u l=0.28u
X334 x1.xamp.vbp1.t7 x1.xamp.vbp1.t6 dvdd.t89 dvdd.t69 pfet_03v3 ad=0.44p pd=2.88u as=0.44p ps=2.88u w=1u l=1u
X335 x1.xtr.nfet_03v3_GP977X_0.S7 x1.xtr.nfet_03v3_GP977X_0.S8 dvss.t32 ppolyf_u r_width=1u r_length=2.63u
X336 x1.xamp.out1p x1.pnp_05p00x05p00_0_0[1|1].E x1.xamp.pfet_03v3_VL4T3E_0.S1_0 dvdd.t34 pfet_03v3 ad=1.76p pd=8.88u as=1.76p ps=8.88u w=4u l=1u
X337 dvss.t163 dvss.t161 dvss.t163 dvss.t162 nfet_03v3 ad=0.88p pd=4.88u as=0 ps=0 w=2u l=4u
X338 x1.xamp.vbn1 x1.xamp.vbn1 dvss.t112 dvss.t359 nfet_03v3 ad=0.43415p pd=2.88u as=0.43415p ps=2.88u w=1u l=1u
X339 x1.xtr.nfet_03v3_GP977X_0.S4 x1.xtr.nfet_03v3_GP977X_0.S5 dvss.t19 ppolyf_u r_width=1u r_length=2.63u
X340 gf180mcu_ocd_ip__classab_buffer_0.se_folded_cascode_np_ab_0.vbp1 ibias2_1u ibias2_1u dvdd.t143 pfet_03v3 ad=0.4257p pd=2.88u as=0.4257p ps=2.88u w=1u l=0.5u
X341 x1.xtr.nfet_03v3_GP977X_0.S13 x1.xtr.nfet_03v3_GP977X_0.S14 dvss.t36 ppolyf_u r_width=1u r_length=2.63u
X342 gf180mcu_ocd_ip__classab_buffer_0.se_folded_cascode_np_ab_0.nfet_03v3_XHQ8ZW_0.S0_0 gf180mcu_ocd_ip__classab_buffer_0.se_folded_cascode_np_ab_0.vbn1 dvss.t145 dvss.t75 nfet_03v3 ad=0.44p pd=2.88u as=0.44p ps=2.88u w=1u l=1u
X343 gf180mcu_ocd_ip__classab_buffer_0.se_folded_cascode_np_ab_0.outa1p.t17 gf180mcu_ocd_ip__classab_buffer_0.se_folded_cascode_np_ab_0.pfet_03v3_9TM96F_0.G0_0 gf180mcu_ocd_ip__classab_buffer_0.se_folded_cascode_np_ab_0.pfet_03v3_XWLNX2_0.D.t2 dvdd.t24 pfet_03v3 ad=0.44p pd=2.88u as=0.44p ps=2.88u w=1u l=4u
X344 a_n8227_n25114# trim[5] dvdd.t117 dvdd.t248 pfet_03v3 ad=0.6072p pd=3.64u as=0.3588p ps=1.9u w=1.38u l=0.28u
D10 trim[0] dvdd.t231 diode_pd2nw_03v3 pj=1.93u area=0.2295p
X345 gf180mcu_ocd_ip__classab_buffer_0.se_folded_cascode_np_ab_0.diffb vbg gf180mcu_ocd_ip__classab_buffer_0.se_folded_cascode_np_ab_0.outb1n dvdd.t102 pfet_03v3 ad=1.76p pd=8.88u as=1.76p ps=8.88u w=4u l=1u
X346 x1.xamp.vbp1.t1 x1.xamp.vbp1.t0 dvdd.t88 dvdd.t69 pfet_03v3 ad=0.44p pd=2.88u as=0.44p ps=2.88u w=1u l=1u
X347 a_n3700_n21799# x1.vbg dvss.t33 ppolyf_u r_width=1u r_length=15u
X348 x1.nfet_03v3_EV2W8D_0.S1.t17 ibias1_250n x1.xamp.pfet_03v3_EQVFPB_0.S1_0 dvdd.t253 pfet_03v3 ad=0.86765p pd=4.88u as=0.86765p ps=4.88u w=2u l=0.5u
X349 x1.xamp.vbn2 x1.xamp.vbp1.t33 dvdd.t89 dvdd.t69 pfet_03v3 ad=0.44p pd=2.88u as=0.44p ps=2.88u w=1u l=1u
X350 x1.nfet_03v3_EV2W8D_0.S1.t25 dvss.t63 cap_mim_2f0_m4m5_noshield c_width=22u c_length=22u
X351 dvss.t171 dvss.t171 dvss.t171 dvss.t175 nfet_03v3 ad=0.44p pd=2.88u as=0 ps=0 w=1u l=1u
X352 gf180mcu_ocd_ip__classab_buffer_0.se_folded_cascode_np_ab_0.outa1p.t14 gf180mcu_ocd_ip__classab_buffer_0.se_folded_cascode_np_ab_0.pfet_03v3_9TM96F_0.G0_0 gf180mcu_ocd_ip__classab_buffer_0.se_folded_cascode_np_ab_0.pfet_03v3_XWLNX2_0.D.t13 dvdd.t18 pfet_03v3 ad=0.44p pd=2.88u as=0.44p ps=2.88u w=1u l=4u
X353 x1.xtr.nfet_03v3_GP977X_0.S11 x1.gf180mcu_as_sc_mcu7t3v3__buff_2_4.Y x1.pnp_05p00x05p00_0_0[0|0].E.t30 dvss.t24 nfet_03v3 ad=1.2964p pd=7.08u as=1.2964p ps=7.08u w=3.1u l=0.28u
X354 x1.xtr.nfet_03v3_GP977X_0.S14 x1.xtr.nfet_03v3_GP977X_0.S15 dvss.t17 ppolyf_u r_width=1u r_length=2.63u
X355 x1.xtr.nfet_03v3_GP977X_0.S8 x1.gf180mcu_as_sc_mcu7t3v3__buff_2_7.Y x1.pnp_05p00x05p00_0_0[0|0].E.t0 dvss.t0 nfet_03v3 ad=1.2964p pd=7.08u as=1.2964p ps=7.08u w=3.1u l=0.28u
X356 x1.xamp.out1p x1.pnp_05p00x05p00_0_0[1|1].E x1.xamp.pfet_03v3_VL4T3E_0.S1_0 dvdd.t35 pfet_03v3 ad=1.76p pd=8.88u as=1.76p ps=8.88u w=4u l=1u
X357 dvss.t115 dvss.t112 dvss.t114 dvss.t113 nfet_03v3 ad=0.43415p pd=2.88u as=0 ps=0 w=1u l=1u
D11 trim[5] dvdd.t246 diode_pd2nw_03v3 pj=1.93u area=0.2295p
X358 x1.xtr.top x1.xtr.nfet_03v3_GP977X_0.S1 dvss.t57 ppolyf_u r_width=1u r_length=2.63u
X359 x1.xamp.out1n x1.xamp.vbn1 dvss.t112 dvss.t364 nfet_03v3 ad=0.43415p pd=2.88u as=0.43415p ps=2.88u w=1u l=1u
X360 x1.xamp.pfet_03v3_EQVFPB_0.G1_0.t5 x1.xamp.vbn2 x1.xamp.out1n dvss.t322 nfet_03v3 ad=0.43415p pd=2.88u as=0.43415p ps=2.88u w=1u l=4u
X361 dvdd.t283 x1.xamp.pfet_03v3_EQVFPB_0.G1_0.t29 x1.xamp.pfet_03v3_EQVFPB_0.S1_0 dvdd.t37 pfet_03v3 ad=0.87415p pd=4.88u as=0.87415p ps=4.88u w=2u l=4u
X362 a_n8227_n22202# trim[8] dvss.t6 dvss.t254 nfet_03v3 ad=0.44p pd=2.88u as=0.26p ps=1.52u w=1u l=0.28u
X363 gf180mcu_ocd_ip__classab_buffer_0.se_folded_cascode_np_ab_0.outb1p gf180mcu_ocd_ip__classab_buffer_0.se_folded_cascode_np_ab_0.vbn1 dvss.t204 dvss.t206 nfet_03v3 ad=0.44p pd=2.88u as=0.44p ps=2.88u w=1u l=1u
X364 gf180mcu_ocd_ip__classab_buffer_0.se_folded_cascode_np_ab_0.outa1p.t15 gf180mcu_ocd_ip__classab_buffer_0.se_folded_cascode_np_ab_0.pfet_03v3_9TM96F_0.G0_0 gf180mcu_ocd_ip__classab_buffer_0.se_folded_cascode_np_ab_0.pfet_03v3_XWLNX2_0.D.t4 dvdd.t20 pfet_03v3 ad=0.44p pd=2.88u as=0.44p ps=2.88u w=1u l=4u
X365 x1.xtr.nfet_03v3_GP977X_0.S9 x1.xtr.nfet_03v3_GP977X_0.S10 dvss.t3 ppolyf_u r_width=1u r_length=2.63u
X366 x1.xtr.nfet_03v3_GP977X_0.S9 x1.xtr.nfet_03v3_GP977X_0.S10 dvss.t3 ppolyf_u r_width=1u r_length=2.63u
X367 a_n3700_n18719# a_n598_n19279# dvss.t31 ppolyf_u r_width=1u r_length=15u
X368 gf180mcu_ocd_ip__classab_buffer_0.se_folded_cascode_np_ab_0.outa1n.t21 gf180mcu_ocd_ip__classab_buffer_0.se_folded_cascode_np_ab_0.outa1n.t20 dvdd.t16 dvdd.t292 pfet_03v3 ad=0.44p pd=2.88u as=0.44p ps=2.88u w=1u l=1u
X369 gf180mcu_ocd_ip__classab_buffer_0.se_folded_cascode_np_ab_0.vbp1 gf180mcu_ocd_ip__classab_buffer_0.se_folded_cascode_np_ab_0.vbp1 dvdd.t12 dvdd.t61 pfet_03v3 ad=0.44p pd=2.88u as=0.44p ps=2.88u w=1u l=1u
X370 gf180mcu_ocd_ip__classab_buffer_0.se_folded_cascode_np_ab_0.diffb vbg gf180mcu_ocd_ip__classab_buffer_0.se_folded_cascode_np_ab_0.outb1n dvdd.t97 pfet_03v3 ad=1.76p pd=8.88u as=1.76p ps=8.88u w=4u l=1u
X371 dvdd.t70 dvdd.t70 dvdd.t70 dvdd.t33 pfet_03v3 ad=1.76p pd=8.88u as=0 ps=0 w=4u l=1u
X372 gf180mcu_ocd_ip__classab_buffer_0.se_folded_cascode_np_ab_0.vbp1 ibias2_1u ibias2_1u dvdd.t141 pfet_03v3 ad=0.4257p pd=2.88u as=0.4257p ps=2.88u w=1u l=0.5u
X373 gf180mcu_ocd_ip__classab_buffer_0.se_folded_cascode_np_ab_0.outb1n gf180mcu_ocd_ip__classab_buffer_0.se_folded_cascode_np_ab_0.vbn1 dvss.t204 dvss.t207 nfet_03v3 ad=0.44p pd=2.88u as=0.44p ps=2.88u w=1u l=1u
X374 x1.gf180mcu_as_sc_mcu7t3v3__buff_2_0.Y a_n8227_n29594# dvss.t265 dvss.t264 nfet_03v3 ad=0.26p pd=1.52u as=0.76p ps=3.52u w=1u l=0.28u
X375 x1.xtr.nfet_03v3_GP977X_0.S1 x1.xtr.nfet_03v3_GP977X_0.S2 dvss.t76 ppolyf_u r_width=1u r_length=2.63u
D12 dvss.t324 trim[4] diode_nd2ps_03v3 pj=1.83u area=0.209p
X376 x1.xtr.nfet_03v3_GP977X_0.S2 x1.xtr.nfet_03v3_GP977X_0.S3 dvss.t255 ppolyf_u r_width=1u r_length=2.63u
X377 x1.nfet_03v3_EV2W8D_0.S1.t22 ibias1_250n x1.xamp.pfet_03v3_EQVFPB_0.S1_0 dvdd.t253 pfet_03v3 ad=0.86765p pd=4.88u as=0.86765p ps=4.88u w=2u l=0.5u
X378 a_n8227_n27802# trim[2] dvss.t257 dvss.t332 nfet_03v3 ad=0.44p pd=2.88u as=0.26p ps=1.52u w=1u l=0.28u
X379 x1.xtr.nfet_03v3_GP977X_0.S2 x1.xtr.nfet_03v3_GP977X_0.S3 dvss.t255 ppolyf_u r_width=1u r_length=2.63u
X380 x1.xtr.nfet_03v3_GP977X_0.S15 x1.pnp_05p00x05p00_0_0[0|0].E.t6 dvss.t30 ppolyf_u r_width=1u r_length=2.63u
X381 gf180mcu_ocd_ip__classab_buffer_0.se_folded_cascode_np_ab_0.vbn1 gf180mcu_ocd_ip__classab_buffer_0.se_folded_cascode_np_ab_0.vbn1 dvss.t171 dvss.t172 nfet_03v3 ad=0.44p pd=2.88u as=0.44p ps=2.88u w=1u l=1u
X382 x1.xtr.nfet_03v3_GP977X_0.S15 x1.pnp_05p00x05p00_0_0[0|0].E.t5 dvss.t30 ppolyf_u r_width=1u r_length=2.63u
X383 gf180mcu_ocd_ip__classab_buffer_0.se_folded_cascode_np_ab_0.pfet_03v3_9TM96F_0.G0_0 gf180mcu_ocd_ip__classab_buffer_0.se_folded_cascode_np_ab_0.pfet_03v3_9TM96F_0.G0_0 gf180mcu_ocd_ip__classab_buffer_0.se_folded_cascode_np_ab_0.outa1n.t6 dvdd.t23 pfet_03v3 ad=0.44p pd=2.88u as=0.44p ps=2.88u w=1u l=4u
X384 dvdd.t131 a_n8227_n27802# x1.gf180mcu_as_sc_mcu7t3v3__buff_2_2.Y dvdd.t130 pfet_03v3 ad=0.3588p pd=1.9u as=0.3588p ps=1.9u w=1.38u l=0.28u
X385 gf180mcu_ocd_ip__classab_buffer_0.se_folded_cascode_np_ab_0.outb1n gf180mcu_ocd_ip__classab_buffer_0.se_folded_cascode_np_ab_0.vbn1 dvss.t192 dvss.t191 nfet_03v3 ad=0.44p pd=2.88u as=0.44p ps=2.88u w=1u l=1u
X386 gf180mcu_ocd_ip__classab_buffer_0.se_folded_cascode_np_ab_0.diffb vbg gf180mcu_ocd_ip__classab_buffer_0.se_folded_cascode_np_ab_0.outb1n dvdd.t103 pfet_03v3 ad=1.76p pd=8.88u as=1.76p ps=8.88u w=4u l=1u
X387 dvss.t24 dvss.t25 dvss.t23 ppolyf_u r_width=1u r_length=2.63u
X388 x1.xtr.nfet_03v3_GP977X_0.S8 x1.xtr.nfet_03v3_GP977X_0.S9 dvss.t1 ppolyf_u r_width=1u r_length=2.63u
X389 x1.xtr.nfet_03v3_GP977X_0.S8 x1.xtr.nfet_03v3_GP977X_0.S9 dvss.t410 ppolyf_u r_width=1u r_length=2.63u
X390 gf180mcu_ocd_ip__classab_buffer_0.se_folded_cascode_np_ab_0.diffb gf180mcu_ocd_ip__classab_buffer_0.se_folded_cascode_np_ab_0.vbp1 dvdd.t42 dvdd.t44 pfet_03v3 ad=0.44p pd=2.88u as=0.44p ps=2.88u w=1u l=1u
X391 a_n8227_n28698# trim[1] dvdd.t81 dvdd.t126 pfet_03v3 ad=0.6072p pd=3.64u as=0.3588p ps=1.9u w=1.38u l=0.28u
X392 ibias1_250n ibias1_250n x1.xamp.vbp1.t14 dvdd.t251 pfet_03v3 ad=0.86765p pd=4.88u as=0.86765p ps=4.88u w=2u l=0.5u
X393 gf180mcu_ocd_ip__classab_buffer_0.se_folded_cascode_np_ab_0.outb1n gf180mcu_ocd_ip__classab_buffer_0.se_folded_cascode_np_ab_0.vbn1 dvss.t180 dvss.t215 nfet_03v3 ad=0.44p pd=2.88u as=0.44p ps=2.88u w=1u l=1u
X394 x1.xamp.pfet_03v3_VL4T3E_0.S1_0 x1.xamp.vbp1.t26 dvdd.t70 dvdd.t69 pfet_03v3 ad=0.44p pd=2.88u as=0.44p ps=2.88u w=1u l=1u
X395 gf180mcu_ocd_ip__classab_buffer_0.se_folded_cascode_np_ab_0.pfet_03v3_9TM96F_0.G0_0 gf180mcu_ocd_ip__classab_buffer_0.se_folded_cascode_np_ab_0.pfet_03v3_9TM96F_0.G0_0 gf180mcu_ocd_ip__classab_buffer_0.se_folded_cascode_np_ab_0.outa1n.t7 dvdd.t25 pfet_03v3 ad=0.44p pd=2.88u as=0.44p ps=2.88u w=1u l=4u
D13 trim[14] dvdd.t273 diode_pd2nw_03v3 pj=1.93u area=0.2295p
X396 a_n3700_n19839# a_n598_n20399# dvss.t48 ppolyf_u r_width=1u r_length=15u
X397 dvss.t171 dvss.t171 dvss.t171 dvss.t177 nfet_03v3 ad=0.44p pd=2.88u as=0 ps=0 w=1u l=1u
X398 dvdd.t148 x1.xamp.pfet_03v3_EQVFPB_0.G1_0.t24 x1.xamp.pfet_03v3_EQVFPB_0.S1_1 dvdd.t77 pfet_03v3 ad=0.87415p pd=4.88u as=0.87415p ps=4.88u w=2u l=4u
X399 a_n3700_n22079# a_n598_n21519# dvss.t43 ppolyf_u r_width=1u r_length=15u
X400 dvdd.t107 x1.nfet_03v3_EV2W8D_0.S1.t27 x1.vbg dvdd.t106 pfet_03v3 ad=1.74765p pd=8.88u as=1.74765p ps=8.88u w=4u l=0.5u
X401 gf180mcu_ocd_ip__classab_buffer_0.se_folded_cascode_np_ab_0.nfet_03v3_XHQ8ZW_0.S0_0 gf180mcu_ocd_ip__classab_buffer_0.se_folded_cascode_np_ab_0.vbn1 dvss.t145 dvss.t73 nfet_03v3 ad=0.44p pd=2.88u as=0.44p ps=2.88u w=1u l=1u
D14 trim[10] dvdd.t121 diode_pd2nw_03v3 pj=1.93u area=0.2295p
X402 dvdd.t4 a_n8227_n22202# x1.gf180mcu_as_sc_mcu7t3v3__buff_2_8.Y dvdd.t3 pfet_03v3 ad=0.3588p pd=1.9u as=0.3588p ps=1.9u w=1.38u l=0.28u
X403 a_n8227_n24218# trim[6] dvdd.t1 dvdd.t289 pfet_03v3 ad=0.6072p pd=3.64u as=0.3588p ps=1.9u w=1.38u l=0.28u
D15 trim[1] dvdd.t124 diode_pd2nw_03v3 pj=1.93u area=0.2295p
X404 x1.xtr.nfet_03v3_GP977X_0.S3 x1.xtr.nfet_03v3_GP977X_0.S4 dvss.t27 ppolyf_u r_width=1u r_length=2.63u
X405 gf180mcu_ocd_ip__classab_buffer_0.se_folded_cascode_np_ab_0.outa1n.t25 gf180mcu_ocd_ip__classab_buffer_0.se_folded_cascode_np_ab_0.outa1n.t24 dvdd.t14 dvdd.t29 pfet_03v3 ad=0.44p pd=2.88u as=0.44p ps=2.88u w=1u l=1u
X406 ibias1_250n ibias1_250n x1.xamp.vbp1.t8 dvdd.t249 pfet_03v3 ad=0.86765p pd=4.88u as=0.86765p ps=4.88u w=2u l=0.5u
X407 gf180mcu_ocd_ip__classab_buffer_0.se_folded_cascode_np_ab_0.diffb gf180mcu_ocd_ip__classab_buffer_0.se_folded_cascode_np_ab_0.vbp1 dvdd.t48 dvdd.t49 pfet_03v3 ad=0.44p pd=2.88u as=0.44p ps=2.88u w=1u l=1u
D16 dvss.t336 trim[13] diode_nd2ps_03v3 pj=1.83u area=0.209p
X408 gf180mcu_ocd_ip__classab_buffer_0.se_folded_cascode_np_ab_0.outb1p gf180mcu_ocd_ip__classab_buffer_0.se_folded_cascode_np_ab_0.vbn2 gf180mcu_ocd_ip__classab_buffer_0.se_folded_cascode_np_ab_0.pfet_03v3_XWLNX2_0.D.t36 dvss.t401 nfet_03v3 ad=0.88p pd=4.88u as=0.88p ps=4.88u w=2u l=4u
X409 a_n8227_n19514# trim[11] dvss.t14 dvss.t53 nfet_03v3 ad=0.44p pd=2.88u as=0.26p ps=1.52u w=1u l=0.28u
X410 dvss.t24 dvss.t24 x1.pnp_05p00x05p00_0_0[0|0].E pnp_05p00x05p00
**devattr s=1000000,4000 d=225453094,146072
X411 gf180mcu_ocd_ip__classab_buffer_0.se_folded_cascode_np_ab_0.pfet_03v3_9TM96F_0.G0_0 gf180mcu_ocd_ip__classab_buffer_0.se_folded_cascode_np_ab_0.pfet_03v3_9TM96F_0.G0_0 gf180mcu_ocd_ip__classab_buffer_0.se_folded_cascode_np_ab_0.outa1n.t14 dvdd.t23 pfet_03v3 ad=0.44p pd=2.88u as=0.44p ps=2.88u w=1u l=4u
X412 gf180mcu_ocd_ip__classab_buffer_0.se_folded_cascode_np_ab_0.pfet_03v3_9TM96F_0.G0_0 gf180mcu_ocd_ip__classab_buffer_0.se_folded_cascode_np_ab_0.pfet_03v3_9TM96F_0.G0_0 gf180mcu_ocd_ip__classab_buffer_0.se_folded_cascode_np_ab_0.outa1n.t5 dvdd.t21 pfet_03v3 ad=0.44p pd=2.88u as=0.44p ps=2.88u w=1u l=4u
X413 dvdd.t76 a_n8227_n19514# x1.gf180mcu_as_sc_mcu7t3v3__buff_2_11.Y dvdd.t227 pfet_03v3 ad=0.3588p pd=1.9u as=0.3588p ps=1.9u w=1.38u l=0.28u
X414 x1.xtr.nfet_03v3_GP977X_0.S4 x1.gf180mcu_as_sc_mcu7t3v3__buff_2_11.Y x1.pnp_05p00x05p00_0_0[0|0].E.t4 dvss.t16 nfet_03v3 ad=1.2964p pd=7.08u as=1.2964p ps=7.08u w=3.1u l=0.28u
X415 x1.xtr.nfet_03v3_GP977X_0.S4 x1.xtr.nfet_03v3_GP977X_0.S5 dvss.t19 ppolyf_u r_width=1u r_length=2.63u
X416 x1.xtr.nfet_03v3_GP977X_0.S10 x1.xtr.nfet_03v3_GP977X_0.S11 dvss.t28 ppolyf_u r_width=1u r_length=2.63u
X417 gf180mcu_ocd_ip__classab_buffer_0.se_folded_cascode_np_ab_0.outb1n gf180mcu_ocd_ip__classab_buffer_0.se_folded_cascode_np_ab_0.vbn1 dvss.t180 dvss.t194 nfet_03v3 ad=0.44p pd=2.88u as=0.44p ps=2.88u w=1u l=1u
D17 trim[6] dvdd.t287 diode_pd2nw_03v3 pj=1.93u area=0.2295p
D18 dvss.t307 trim[0] diode_nd2ps_03v3 pj=1.83u area=0.209p
X418 x1.xtr.nfet_03v3_GP977X_0.S10 x1.xtr.nfet_03v3_GP977X_0.S11 dvss.t28 ppolyf_u r_width=1u r_length=2.63u
X419 x1.xtr.nfet_03v3_GP977X_0.S1 x1.gf180mcu_as_sc_mcu7t3v3__buff_2_14.Y x1.pnp_05p00x05p00_0_0[0|0].E.t26 dvss.t293 nfet_03v3 ad=1.2964p pd=7.08u as=1.2964p ps=7.08u w=3.1u l=0.28u
X420 gf180mcu_ocd_ip__classab_buffer_0.se_folded_cascode_np_ab_0.vbn1 gf180mcu_ocd_ip__classab_buffer_0.se_folded_cascode_np_ab_0.vbn1 dvss.t195 dvss.t173 nfet_03v3 ad=0.44p pd=2.88u as=0.44p ps=2.88u w=1u l=1u
X421 gf180mcu_ocd_ip__classab_buffer_0.se_folded_cascode_np_ab_0.outa1p.t2 gf180mcu_ocd_ip__classab_buffer_0.se_folded_cascode_np_ab_0.pfet_03v3_9TM96F_0.G0_0 gf180mcu_ocd_ip__classab_buffer_0.se_folded_cascode_np_ab_0.pfet_03v3_XWLNX2_0.D.t6 dvdd.t19 pfet_03v3 ad=0.44p pd=2.88u as=0.44p ps=2.88u w=1u l=4u
X422 a_n8227_n21306# trim[9] dvss.t10 dvss.t268 nfet_03v3 ad=0.44p pd=2.88u as=0.26p ps=1.52u w=1u l=0.28u
X423 gf180mcu_ocd_ip__classab_buffer_0.se_folded_cascode_np_ab_0.outb1p gf180mcu_ocd_ip__classab_buffer_0.se_folded_cascode_np_ab_0.vbn1 dvss.t204 dvss.t203 nfet_03v3 ad=0.44p pd=2.88u as=0.44p ps=2.88u w=1u l=1u
X424 gf180mcu_ocd_ip__classab_buffer_0.se_folded_cascode_np_ab_0.outb1p gf180mcu_ocd_ip__classab_buffer_0.se_folded_cascode_np_ab_0.vbn1 dvss.t180 dvss.t214 nfet_03v3 ad=0.44p pd=2.88u as=0.44p ps=2.88u w=1u l=1u
X425 gf180mcu_ocd_ip__classab_buffer_0.se_folded_cascode_np_ab_0.pfet_03v3_9TM96F_0.G0_0 gf180mcu_ocd_ip__classab_buffer_0.se_folded_cascode_np_ab_0.pfet_03v3_9TM96F_0.G0_0 gf180mcu_ocd_ip__classab_buffer_0.se_folded_cascode_np_ab_0.outa1n.t15 dvdd.t25 pfet_03v3 ad=0.44p pd=2.88u as=0.44p ps=2.88u w=1u l=4u
X426 x1.xamp.pfet_03v3_VL4T3E_0.S1_0 x1.xamp.vbp1.t21 dvdd.t70 dvdd.t69 pfet_03v3 ad=0.44p pd=2.88u as=0.44p ps=2.88u w=1u l=1u
X427 gf180mcu_ocd_ip__classab_buffer_0.se_folded_cascode_np_ab_0.outb1p gf180mcu_ocd_ip__classab_buffer_0.se_folded_cascode_np_ab_0.vbn2 gf180mcu_ocd_ip__classab_buffer_0.se_folded_cascode_np_ab_0.pfet_03v3_XWLNX2_0.D.t34 dvss.t397 nfet_03v3 ad=0.88p pd=4.88u as=0.88p ps=4.88u w=2u l=4u
X428 x1.xamp.out1p x1.pnp_05p00x05p00_0_0[1|1].E x1.xamp.pfet_03v3_VL4T3E_0.S1_0 dvdd.t33 pfet_03v3 ad=1.76p pd=8.88u as=1.76p ps=8.88u w=4u l=1u
X429 x1.xamp.pfet_03v3_VL4T3E_0.S1_0 x1.xamp.vbp1.t16 dvdd.t70 dvdd.t69 pfet_03v3 ad=0.44p pd=2.88u as=0.44p ps=2.88u w=1u l=1u
X430 dvdd.t213 a_n8227_n15034# x1.ena_buf dvdd.t220 pfet_03v3 ad=0.3588p pd=1.9u as=0.3588p ps=1.9u w=1.38u l=0.28u
X431 x1.gf180mcu_as_sc_mcu7t3v3__buff_2_1.Y a_n8227_n28698# dvss.t60 dvss.t61 nfet_03v3 ad=0.26p pd=1.52u as=0.76p ps=3.52u w=1u l=0.28u
X432 x1.xtr.nfet_03v3_GP977X_0.S11 x1.xtr.nfet_03v3_GP977X_0.S12 dvss.t20 ppolyf_u r_width=1u r_length=2.63u
X433 x1.xtr.nfet_03v3_GP977X_0.S11 x1.xtr.nfet_03v3_GP977X_0.S12 dvss.t20 ppolyf_u r_width=1u r_length=2.63u
X434 dvdd.t1 a_n8227_n23322# x1.gf180mcu_as_sc_mcu7t3v3__buff_2_7.Y dvdd.t0 pfet_03v3 ad=0.3588p pd=1.9u as=0.3588p ps=1.9u w=1.38u l=0.28u
D19 dvss.t327 trim[5] diode_nd2ps_03v3 pj=1.83u area=0.209p
X435 dvdd.t78 x1.xamp.pfet_03v3_EQVFPB_0.G1_0.t28 x1.xamp.pfet_03v3_EQVFPB_0.S1_1 dvdd.t77 pfet_03v3 ad=0.87415p pd=4.88u as=0.87415p ps=4.88u w=2u l=4u
X436 a_n8227_n26906# trim[3] dvss.t257 dvss.t271 nfet_03v3 ad=0.44p pd=2.88u as=0.26p ps=1.52u w=1u l=0.28u
X437 x1.xamp.pfet_03v3_EQVFPB_0.G1_0.t3 x1.xamp.vbn2 x1.xamp.out1n dvss.t4 nfet_03v3 ad=0.43415p pd=2.88u as=0.43415p ps=2.88u w=1u l=4u
X438 gf180mcu_ocd_ip__classab_buffer_0.se_folded_cascode_np_ab_0.outb1n gf180mcu_ocd_ip__classab_buffer_0.se_folded_cascode_np_ab_0.vbn2 gf180mcu_ocd_ip__classab_buffer_0.se_folded_cascode_np_ab_0.pfet_03v3_9TM96F_0.G0_0 dvss.t401 nfet_03v3 ad=0.88p pd=4.88u as=0.88p ps=4.88u w=2u l=4u
X439 gf180mcu_ocd_ip__classab_buffer_0.se_folded_cascode_np_ab_0.nfet_03v3_XHQ8ZW_0.S0_0 gf180mcu_ocd_ip__classab_buffer_0.se_folded_cascode_np_ab_0.vbn1 dvss.t145 dvss.t74 nfet_03v3 ad=0.44p pd=2.88u as=0.44p ps=2.88u w=1u l=1u
X440 dvdd.t131 a_n8227_n26906# x1.gf180mcu_as_sc_mcu7t3v3__buff_2_3.Y dvdd.t133 pfet_03v3 ad=0.3588p pd=1.9u as=0.3588p ps=1.9u w=1.38u l=0.28u
X441 x1.xamp.out1n x1.xamp.vbn1 dvss.t83 dvss.t374 nfet_03v3 ad=0.43415p pd=2.88u as=0.43415p ps=2.88u w=1u l=1u
X442 gf180mcu_ocd_ip__classab_buffer_0.se_folded_cascode_np_ab_0.diffb vbg gf180mcu_ocd_ip__classab_buffer_0.se_folded_cascode_np_ab_0.outb1n dvdd.t101 pfet_03v3 ad=1.76p pd=8.88u as=1.76p ps=8.88u w=4u l=1u
X443 dvdd.t154 dvdd.t154 dvdd.t154 dvdd.t37 pfet_03v3 ad=0.87415p pd=4.88u as=0 ps=0 w=2u l=4u
X444 x1.xtr.top x1.xamp.inp dvss.t50 ppolyf_u r_width=1u r_length=15u
X445 x1.xtr.nfet_03v3_GP977X_0.S12 x1.xtr.nfet_03v3_GP977X_0.S13 dvss.t41 ppolyf_u r_width=1u r_length=2.63u
X446 x1.xtr.nfet_03v3_GP977X_0.S12 x1.xtr.nfet_03v3_GP977X_0.S13 dvss.t41 ppolyf_u r_width=1u r_length=2.63u
X447 x1.xamp.out1p x1.xamp.vbn1 dvss.t83 dvss.t383 nfet_03v3 ad=0.43415p pd=2.88u as=0.43415p ps=2.88u w=1u l=1u
X448 dvss.t279 x1.ena_buf gf180mcu_ocd_ip__classab_buffer_0.se_folded_cascode_np_ab_0.nfet_03v3_XRMCLC_0.S0_0 dvss.t278 nfet_03v3 ad=1.73465p pd=8.88u as=1.73465p ps=8.88u w=4u l=0.28u
X449 gf180mcu_ocd_ip__classab_buffer_0.se_folded_cascode_np_ab_0.pfet_03v3_9TM96F_0.G0_0 gf180mcu_ocd_ip__classab_buffer_0.se_folded_cascode_np_ab_0.pfet_03v3_9TM96F_0.G0_0 gf180mcu_ocd_ip__classab_buffer_0.se_folded_cascode_np_ab_0.outa1n.t13 dvdd.t21 pfet_03v3 ad=0.44p pd=2.88u as=0.44p ps=2.88u w=1u l=4u
X450 gf180mcu_ocd_ip__classab_buffer_0.se_folded_cascode_np_ab_0.diffb vbg gf180mcu_ocd_ip__classab_buffer_0.se_folded_cascode_np_ab_0.outb1n dvdd.t100 pfet_03v3 ad=1.76p pd=8.88u as=1.76p ps=8.88u w=4u l=1u
D20 trim[8] dvdd.t127 diode_pd2nw_03v3 pj=1.93u area=0.2295p
D21 trim[15] dvdd.t264 diode_pd2nw_03v3 pj=1.93u area=0.2295p
X451 gf180mcu_ocd_ip__classab_buffer_0.se_folded_cascode_np_ab_0.outb1p gf180mcu_ocd_ip__classab_buffer_0.se_folded_cascode_np_ab_0.vbn1 dvss.t180 dvss.t213 nfet_03v3 ad=0.44p pd=2.88u as=0.44p ps=2.88u w=1u l=1u
X452 x1.xtr.nfet_03v3_GP977X_0.S15 x1.pnp_05p00x05p00_0_0[0|0].E.t32 dvss.t30 ppolyf_u r_width=1u r_length=2.63u
X453 gf180mcu_ocd_ip__classab_buffer_0.se_folded_cascode_np_ab_0.outb1n gf180mcu_ocd_ip__classab_buffer_0.se_folded_cascode_np_ab_0.vbn2 gf180mcu_ocd_ip__classab_buffer_0.se_folded_cascode_np_ab_0.pfet_03v3_9TM96F_0.G0_0 dvss.t397 nfet_03v3 ad=0.88p pd=4.88u as=0.88p ps=4.88u w=2u l=4u
X454 ibias1_250n ibias1_250n x1.xamp.vbp1.t9 dvdd.t250 pfet_03v3 ad=0.86765p pd=4.88u as=0.86765p ps=4.88u w=2u l=0.5u
X455 gf180mcu_ocd_ip__classab_buffer_0.se_folded_cascode_np_ab_0.nfet_03v3_XHQ8ZW_0.S0_0 gf180mcu_ocd_ip__classab_buffer_0.se_folded_cascode_np_ab_0.vbn1 dvss.t145 dvss.t71 nfet_03v3 ad=0.44p pd=2.88u as=0.44p ps=2.88u w=1u l=1u
X456 dvdd.t7 a_n8227_n21306# x1.gf180mcu_as_sc_mcu7t3v3__buff_2_9.Y dvdd.t6 pfet_03v3 ad=0.3588p pd=1.9u as=0.3588p ps=1.9u w=1.38u l=0.28u
X457 x1.xamp.pfet_03v3_EQVFPB_0.G1_0.t0 x1.xamp.vbn2 x1.xamp.out1n dvss.t318 nfet_03v3 ad=0.43415p pd=2.88u as=0.43415p ps=2.88u w=1u l=4u
X458 gf180mcu_ocd_ip__classab_buffer_0.se_folded_cascode_np_ab_0.diffb gf180mcu_ocd_ip__classab_buffer_0.se_folded_cascode_np_ab_0.vbp1 dvdd.t42 dvdd.t45 pfet_03v3 ad=0.44p pd=2.88u as=0.44p ps=2.88u w=1u l=1u
D22 trim[2] dvdd.t260 diode_pd2nw_03v3 pj=1.93u area=0.2295p
X459 x1.xamp.out1n x1.xamp.vbn1 dvss.t83 dvss.t383 nfet_03v3 ad=0.43415p pd=2.88u as=0.43415p ps=2.88u w=1u l=1u
X460 x1.xtr.nfet_03v3_GP977X_0.S13 x1.gf180mcu_as_sc_mcu7t3v3__buff_2_2.Y x1.pnp_05p00x05p00_0_0[0|0].E.t11 dvss.t62 nfet_03v3 ad=1.2964p pd=7.08u as=1.2964p ps=7.08u w=3.1u l=0.28u
X461 dvss.t279 x1.ena_buf gf180mcu_ocd_ip__classab_buffer_0.se_folded_cascode_np_ab_0.nfet_03v3_XRMCLC_0.S0_0 dvss.t285 nfet_03v3 ad=1.73465p pd=8.88u as=1.73465p ps=8.88u w=4u l=0.28u
X462 dvdd.t70 dvdd.t70 dvdd.t70 dvdd.t36 pfet_03v3 ad=1.76p pd=8.88u as=0 ps=0 w=4u l=1u
X463 dvss.t291 a_n8227_n17722# x1.gf180mcu_as_sc_mcu7t3v3__buff_2_13.Y dvss.t290 nfet_03v3 ad=0.26p pd=1.52u as=0.26p ps=1.52u w=1u l=0.28u
X464 dvdd.t150 dvdd.t150 dvdd.t150 dvdd.t37 pfet_03v3 ad=0.87415p pd=4.88u as=0 ps=0 w=2u l=4u
D23 dvss.t342 trim[14] diode_nd2ps_03v3 pj=1.83u area=0.209p
X465 gf180mcu_ocd_ip__classab_buffer_0.se_folded_cascode_np_ab_0.outb1p gf180mcu_ocd_ip__classab_buffer_0.se_folded_cascode_np_ab_0.vbn2 gf180mcu_ocd_ip__classab_buffer_0.se_folded_cascode_np_ab_0.pfet_03v3_XWLNX2_0.D.t28 dvss.t401 nfet_03v3 ad=0.88p pd=4.88u as=0.88p ps=4.88u w=2u l=4u
X466 gf180mcu_ocd_ip__classab_buffer_0.se_folded_cascode_np_ab_0.vbp1 ibias2_1u ibias2_1u dvdd.t141 pfet_03v3 ad=0.4257p pd=2.88u as=0.4257p ps=2.88u w=1u l=0.5u
X467 x1.gf180mcu_as_sc_mcu7t3v3__buff_2_13.Y a_n8227_n17722# dvdd.t223 dvdd.t224 pfet_03v3 ad=0.3588p pd=1.9u as=1.0488p ps=4.28u w=1.38u l=0.28u
X468 a_n8227_n18618# trim[12] dvss.t291 dvss.t353 nfet_03v3 ad=0.44p pd=2.88u as=0.26p ps=1.52u w=1u l=0.28u
X469 gf180mcu_ocd_ip__classab_buffer_0.se_folded_cascode_np_ab_0.vbn2 gf180mcu_ocd_ip__classab_buffer_0.se_folded_cascode_np_ab_0.vbn2 gf180mcu_ocd_ip__classab_buffer_0.se_folded_cascode_np_ab_0.vbn1 dvss.t395 nfet_03v3 ad=0.88p pd=4.88u as=0.88p ps=4.88u w=2u l=4u
X470 a_n3700_n16479# a_n598_n17039# dvss.t35 ppolyf_u r_width=1u r_length=15u
X471 dvdd.t76 a_n8227_n18618# x1.gf180mcu_as_sc_mcu7t3v3__buff_2_12.Y dvdd.t229 pfet_03v3 ad=0.3588p pd=1.9u as=0.3588p ps=1.9u w=1.38u l=0.28u
X472 dvss.t60 a_n8227_n29594# x1.gf180mcu_as_sc_mcu7t3v3__buff_2_0.Y dvss.t263 nfet_03v3 ad=0.26p pd=1.52u as=0.26p ps=1.52u w=1u l=0.28u
X473 x1.nfet_03v3_EV2W8D_0.S1.t8 ibias1_250n x1.xamp.pfet_03v3_EQVFPB_0.S1_0 dvdd.t253 pfet_03v3 ad=0.86765p pd=4.88u as=0.86765p ps=4.88u w=2u l=0.5u
X474 dvdd.t243 x1.xamp.pfet_03v3_EQVFPB_0.G1_0.t33 x1.xamp.pfet_03v3_EQVFPB_0.S1_0 dvdd.t37 pfet_03v3 ad=0.87415p pd=4.88u as=0.87415p ps=4.88u w=2u l=4u
D24 trim[7] dvdd.t236 diode_pd2nw_03v3 pj=1.93u area=0.2295p
D25 dvss.t249 trim[1] diode_nd2ps_03v3 pj=1.83u area=0.209p
X475 gf180mcu_ocd_ip__classab_buffer_0.se_folded_cascode_np_ab_0.outb1n gf180mcu_ocd_ip__classab_buffer_0.se_folded_cascode_np_ab_0.vbn1 dvss.t180 dvss.t212 nfet_03v3 ad=0.44p pd=2.88u as=0.44p ps=2.88u w=1u l=1u
X476 x1.xtr.nfet_03v3_GP977X_0.S14 x1.gf180mcu_as_sc_mcu7t3v3__buff_2_1.Y x1.pnp_05p00x05p00_0_0[0|0].E.t10 dvss.t58 nfet_03v3 ad=1.2964p pd=7.08u as=1.2964p ps=7.08u w=3.1u l=0.28u
X477 dvss.t139 dvss.t128 dvss.t138 dvss.t125 nfet_03v3 ad=0.43415p pd=2.88u as=0 ps=0 w=1u l=1u
X478 dvss.t108 dvss.t79 dvss.t107 dvss.t106 nfet_03v3 ad=0.43415p pd=2.88u as=0 ps=0 w=1u l=1u
X479 gf180mcu_ocd_ip__classab_buffer_0.se_folded_cascode_np_ab_0.outb1p gf180mcu_ocd_ip__classab_buffer_0.se_folded_cascode_np_ab_0.vbn2 gf180mcu_ocd_ip__classab_buffer_0.se_folded_cascode_np_ab_0.pfet_03v3_XWLNX2_0.D.t26 dvss.t397 nfet_03v3 ad=0.88p pd=4.88u as=0.88p ps=4.88u w=2u l=4u
X480 x1.xamp.out1p x1.pnp_05p00x05p00_0_0[1|1].E x1.xamp.pfet_03v3_VL4T3E_0.S1_0 dvdd.t33 pfet_03v3 ad=1.76p pd=8.88u as=1.76p ps=8.88u w=4u l=1u
X481 dvss.t242 a_n8227_n25114# x1.gf180mcu_as_sc_mcu7t3v3__buff_2_5.Y dvss.t24 nfet_03v3 ad=0.26p pd=1.52u as=0.26p ps=1.52u w=1u l=0.28u
X482 gf180mcu_ocd_ip__classab_buffer_0.se_folded_cascode_np_ab_0.outb1n gf180mcu_ocd_ip__classab_buffer_0.se_folded_cascode_np_ab_0.vbn2 gf180mcu_ocd_ip__classab_buffer_0.se_folded_cascode_np_ab_0.pfet_03v3_9TM96F_0.G0_0 dvss.t402 nfet_03v3 ad=0.88p pd=4.88u as=0.88p ps=4.88u w=2u l=4u
X483 dvdd.t160 dvdd.t161 dvdd.t163 dvdd.t162 pfet_03v3 ad=0.4257p pd=2.88u as=0 ps=0 w=1u l=0.5u
D26 dvss.t3 trim[6] diode_nd2ps_03v3 pj=1.83u area=0.209p
X484 dvss.t140 dvss.t140 dvss.t142 dvss.t141 nfet_03v3 ad=0.43415p pd=2.88u as=0 ps=0 w=1u l=2u
X485 ibias1_250n ibias1_250n x1.xamp.vbp1.t11 dvdd.t252 pfet_03v3 ad=0.86765p pd=4.88u as=0.86765p ps=4.88u w=2u l=0.5u
X486 a_n8227_n26010# trim[4] dvss.t242 dvss.t326 nfet_03v3 ad=0.44p pd=2.88u as=0.26p ps=1.52u w=1u l=0.28u
X487 x1.xtr.nfet_03v3_GP977X_0.S13 x1.xtr.nfet_03v3_GP977X_0.S14 dvss.t36 ppolyf_u r_width=1u r_length=2.63u
X488 x1.xtr.nfet_03v3_GP977X_0.S13 x1.xtr.nfet_03v3_GP977X_0.S14 dvss.t36 ppolyf_u r_width=1u r_length=2.63u
X489 dvdd.t107 x1.nfet_03v3_EV2W8D_0.S1.t29 x1.vbg dvdd.t298 pfet_03v3 ad=1.74765p pd=8.88u as=1.74765p ps=8.88u w=4u l=0.5u
X490 dvdd.t117 a_n8227_n26010# x1.gf180mcu_as_sc_mcu7t3v3__buff_2_4.Y dvdd.t234 pfet_03v3 ad=0.3588p pd=1.9u as=0.3588p ps=1.9u w=1.38u l=0.28u
X491 a_n3700_n17599# a_n598_n18159# dvss.t272 ppolyf_u r_width=1u r_length=15u
X492 gf180mcu_ocd_ip__classab_buffer_0.se_folded_cascode_np_ab_0.diffb x1.vbg gf180mcu_ocd_ip__classab_buffer_0.se_folded_cascode_np_ab_0.outb1p dvdd.t99 pfet_03v3 ad=1.76p pd=8.88u as=1.76p ps=8.88u w=4u l=1u
X493 gf180mcu_ocd_ip__classab_buffer_0.se_folded_cascode_np_ab_0.diffb gf180mcu_ocd_ip__classab_buffer_0.se_folded_cascode_np_ab_0.vbp1 dvdd.t48 dvdd.t47 pfet_03v3 ad=0.44p pd=2.88u as=0.44p ps=2.88u w=1u l=1u
X494 dvss.t82 dvss.t79 dvss.t81 dvss.t80 nfet_03v3 ad=0.43415p pd=2.88u as=0 ps=0 w=1u l=1u
X495 gf180mcu_ocd_ip__classab_buffer_0.se_folded_cascode_np_ab_0.outa1n.t23 gf180mcu_ocd_ip__classab_buffer_0.se_folded_cascode_np_ab_0.outa1n.t22 dvdd.t16 dvdd.t27 pfet_03v3 ad=0.44p pd=2.88u as=0.44p ps=2.88u w=1u l=1u
X496 gf180mcu_ocd_ip__classab_buffer_0.se_folded_cascode_np_ab_0.outa1p.t21 gf180mcu_ocd_ip__classab_buffer_0.se_folded_cascode_np_ab_0.outa1n.t59 dvdd.t12 dvdd.t71 pfet_03v3 ad=0.44p pd=2.88u as=0.44p ps=2.88u w=1u l=1u
X497 gf180mcu_ocd_ip__classab_buffer_0.se_folded_cascode_np_ab_0.diffb vbg gf180mcu_ocd_ip__classab_buffer_0.se_folded_cascode_np_ab_0.outb1n dvdd.t98 pfet_03v3 ad=1.76p pd=8.88u as=1.76p ps=8.88u w=4u l=1u
X498 dvss.t121 dvss.t112 dvss.t120 dvss.t119 nfet_03v3 ad=0.43415p pd=2.88u as=0 ps=0 w=1u l=1u
X499 x1.nfet_03v3_EV2W8D_0.S1.t13 ibias1_250n x1.xamp.pfet_03v3_EQVFPB_0.S1_0 dvdd.t253 pfet_03v3 ad=0.86765p pd=4.88u as=0.86765p ps=4.88u w=2u l=0.5u
X500 x1.xamp.out1p x1.xamp.vbn1 dvss.t112 dvss.t366 nfet_03v3 ad=0.43415p pd=2.88u as=0.43415p ps=2.88u w=1u l=1u
X501 gf180mcu_ocd_ip__classab_buffer_0.se_folded_cascode_np_ab_0.outb1p gf180mcu_ocd_ip__classab_buffer_0.se_folded_cascode_np_ab_0.vbn1 dvss.t180 dvss.t209 nfet_03v3 ad=0.44p pd=2.88u as=0.44p ps=2.88u w=1u l=1u
X502 x1.xtr.nfet_03v3_GP977X_0.S14 x1.xtr.nfet_03v3_GP977X_0.S15 dvss.t17 ppolyf_u r_width=1u r_length=2.63u
X503 x1.xtr.nfet_03v3_GP977X_0.S14 x1.xtr.nfet_03v3_GP977X_0.S15 dvss.t17 ppolyf_u r_width=1u r_length=2.63u
X504 x1.nfet_03v3_EV2W8D_0.S1.t7 x1.xamp.vbn2 x1.xamp.out1p dvss.t323 nfet_03v3 ad=0.43415p pd=2.88u as=0.43415p ps=2.88u w=1u l=4u
X505 gf180mcu_ocd_ip__classab_buffer_0.se_folded_cascode_np_ab_0.outb1n gf180mcu_ocd_ip__classab_buffer_0.se_folded_cascode_np_ab_0.vbn2 gf180mcu_ocd_ip__classab_buffer_0.se_folded_cascode_np_ab_0.pfet_03v3_9TM96F_0.G0_0 dvss.t398 nfet_03v3 ad=0.88p pd=4.88u as=0.88p ps=4.88u w=2u l=4u
X506 gf180mcu_ocd_ip__classab_buffer_0.se_folded_cascode_np_ab_0.outb1p gf180mcu_ocd_ip__classab_buffer_0.se_folded_cascode_np_ab_0.vbn1 dvss.t192 dvss.t202 nfet_03v3 ad=0.44p pd=2.88u as=0.44p ps=2.88u w=1u l=1u
X507 x1.xamp.vbp1.t3 x1.xamp.vbp1.t2 dvdd.t89 dvdd.t69 pfet_03v3 ad=0.44p pd=2.88u as=0.44p ps=2.88u w=1u l=1u
X508 dvdd.t154 dvdd.t154 dvdd.t154 dvdd.t77 pfet_03v3 ad=0.87415p pd=4.88u as=0 ps=0 w=2u l=4u
X509 a_n8227_n20410# trim[10] dvss.t14 dvss.t248 nfet_03v3 ad=0.44p pd=2.88u as=0.26p ps=1.52u w=1u l=0.28u
X510 dvss.t279 x1.ena_buf gf180mcu_ocd_ip__classab_buffer_0.se_folded_cascode_np_ab_0.nfet_03v3_XRMCLC_0.S0_0 dvss.t283 nfet_03v3 ad=1.73465p pd=8.88u as=1.73465p ps=8.88u w=4u l=0.28u
X511 x1.xtr.top x1.xtr.nfet_03v3_GP977X_0.S1 dvss.t57 ppolyf_u r_width=1u r_length=2.63u
X512 x1.xtr.top x1.xtr.nfet_03v3_GP977X_0.S1 dvss.t57 ppolyf_u r_width=1u r_length=2.63u
X513 x1.nfet_03v3_EV2W8D_0.S1.t6 x1.xamp.vbn2 x1.xamp.out1p dvss.t323 nfet_03v3 ad=0.43415p pd=2.88u as=0.43415p ps=2.88u w=1u l=4u
X514 x1.xamp.vbn2 x1.xamp.vbp1.t32 dvdd.t89 dvdd.t69 pfet_03v3 ad=0.44p pd=2.88u as=0.44p ps=2.88u w=1u l=1u
X515 dvdd.t38 x1.xamp.pfet_03v3_EQVFPB_0.G1_0.t27 x1.xamp.pfet_03v3_EQVFPB_0.S1_1 dvdd.t37 pfet_03v3 ad=0.87415p pd=4.88u as=0.87415p ps=4.88u w=2u l=4u
X516 gf180mcu_ocd_ip__classab_buffer_0.se_folded_cascode_np_ab_0.nfet_03v3_XHQ8ZW_0.S0_0 gf180mcu_ocd_ip__classab_buffer_0.se_folded_cascode_np_ab_0.vbn1 dvss.t145 dvss.t69 nfet_03v3 ad=0.44p pd=2.88u as=0.44p ps=2.88u w=1u l=1u
X517 dvdd.t107 x1.nfet_03v3_EV2W8D_0.S1.t28 x1.pfet_03v3_73PQE5_0.S0 dvdd.t147 pfet_03v3 ad=1.74765p pd=8.88u as=1.74765p ps=8.88u w=4u l=0.5u
X518 gf180mcu_ocd_ip__classab_buffer_0.se_folded_cascode_np_ab_0.diffb vbg gf180mcu_ocd_ip__classab_buffer_0.se_folded_cascode_np_ab_0.outb1n dvdd.t104 pfet_03v3 ad=1.76p pd=8.88u as=1.76p ps=8.88u w=4u l=1u
X519 dvss.t24 dvss.t24 x1.pnp_05p00x05p00_0_0[0|0].E pnp_05p00x05p00
**devattr s=1000000,4000 d=225453094,146072
X520 dvdd.t7 a_n8227_n20410# x1.gf180mcu_as_sc_mcu7t3v3__buff_2_10.Y dvdd.t9 pfet_03v3 ad=0.3588p pd=1.9u as=0.3588p ps=1.9u w=1.38u l=0.28u
X521 gf180mcu_ocd_ip__classab_buffer_0.se_folded_cascode_np_ab_0.outb1p gf180mcu_ocd_ip__classab_buffer_0.se_folded_cascode_np_ab_0.vbn2 gf180mcu_ocd_ip__classab_buffer_0.se_folded_cascode_np_ab_0.pfet_03v3_XWLNX2_0.D.t33 dvss.t402 nfet_03v3 ad=0.88p pd=4.88u as=0.88p ps=4.88u w=2u l=4u
X522 gf180mcu_ocd_ip__classab_buffer_0.se_folded_cascode_np_ab_0.vbp1 ibias2_1u ibias2_1u dvdd.t142 pfet_03v3 ad=0.4257p pd=2.88u as=0.4257p ps=2.88u w=1u l=0.5u
X523 dvss.t276 a_n8227_n16826# x1.gf180mcu_as_sc_mcu7t3v3__buff_2_14.Y dvss.t294 nfet_03v3 ad=0.26p pd=1.52u as=0.26p ps=1.52u w=1u l=0.28u
X524 gf180mcu_ocd_ip__classab_buffer_0.se_folded_cascode_np_ab_0.outb1p gf180mcu_ocd_ip__classab_buffer_0.se_folded_cascode_np_ab_0.vbn1 dvss.t171 dvss.t198 nfet_03v3 ad=0.44p pd=2.88u as=0.44p ps=2.88u w=1u l=1u
X525 dvdd.t70 dvdd.t70 dvdd.t70 dvdd.t36 pfet_03v3 ad=1.76p pd=8.88u as=0 ps=0 w=4u l=1u
X526 x1.xamp.out1p x1.xamp.vbn1 dvss.t112 dvss.t356 nfet_03v3 ad=0.43415p pd=2.88u as=0.43415p ps=2.88u w=1u l=1u
X527 gf180mcu_ocd_ip__classab_buffer_0.se_folded_cascode_np_ab_0.outb1n gf180mcu_ocd_ip__classab_buffer_0.se_folded_cascode_np_ab_0.vbn2 gf180mcu_ocd_ip__classab_buffer_0.se_folded_cascode_np_ab_0.pfet_03v3_9TM96F_0.G0_0 dvss.t400 nfet_03v3 ad=0.88p pd=4.88u as=0.88p ps=4.88u w=2u l=4u
X528 x1.xamp.out1n x1.xamp.inp x1.xamp.pfet_03v3_VL4T3E_0.S1_0 dvdd.t34 pfet_03v3 ad=1.76p pd=8.88u as=1.76p ps=8.88u w=4u l=1u
X529 x1.nfet_03v3_EV2W8D_0.S1.t11 ibias1_250n x1.xamp.pfet_03v3_EQVFPB_0.S1_0 dvdd.t253 pfet_03v3 ad=0.86765p pd=4.88u as=0.86765p ps=4.88u w=2u l=0.5u
X530 x1.gf180mcu_as_sc_mcu7t3v3__buff_2_14.Y a_n8227_n16826# dvdd.t223 dvdd.t226 pfet_03v3 ad=0.3588p pd=1.9u as=1.0488p ps=4.28u w=1.38u l=0.28u
X531 x1.xtr.nfet_03v3_GP977X_0.S1 x1.xtr.nfet_03v3_GP977X_0.S2 dvss.t76 ppolyf_u r_width=1u r_length=2.63u
X532 gf180mcu_ocd_ip__classab_buffer_0.se_folded_cascode_np_ab_0.outa1p.t10 gf180mcu_ocd_ip__classab_buffer_0.se_folded_cascode_np_ab_0.pfet_03v3_9TM96F_0.G0_0 gf180mcu_ocd_ip__classab_buffer_0.se_folded_cascode_np_ab_0.pfet_03v3_XWLNX2_0.D.t14 dvdd.t19 pfet_03v3 ad=0.44p pd=2.88u as=0.44p ps=2.88u w=1u l=4u
X533 x1.gf180mcu_as_sc_mcu7t3v3__buff_2_5.Y a_n8227_n25114# dvdd.t117 dvdd.t118 pfet_03v3 ad=0.3588p pd=1.9u as=1.0488p ps=4.28u w=1.38u l=0.28u
X534 x1.gf180mcu_as_sc_mcu7t3v3__buff_2_2.Y a_n8227_n27802# dvss.t257 dvss.t258 nfet_03v3 ad=0.26p pd=1.52u as=0.76p ps=3.52u w=1u l=0.28u
X535 x1.xtr.nfet_03v3_GP977X_0.S1 x1.xtr.nfet_03v3_GP977X_0.S2 dvss.t76 ppolyf_u r_width=1u r_length=2.63u
X536 a_n3700_n20959# a_n598_n20399# dvss.t42 ppolyf_u r_width=1u r_length=15u
X537 a_n8227_n15034# ena dvdd.t213 dvdd.t272 pfet_03v3 ad=0.6072p pd=3.64u as=0.3588p ps=1.9u w=1.38u l=0.28u
X538 dvss.t60 a_n8227_n28698# x1.gf180mcu_as_sc_mcu7t3v3__buff_2_1.Y dvss.t59 nfet_03v3 ad=0.26p pd=1.52u as=0.26p ps=1.52u w=1u l=0.28u
X539 a_n8227_n23322# trim[7] dvdd.t1 dvdd.t238 pfet_03v3 ad=0.6072p pd=3.64u as=0.3588p ps=1.9u w=1.38u l=0.28u
X540 x1.pfet_03v3_BWTVHK_0.D dvdd.t299 dvss.t273 x1.pfet_03v3_BWTVHK_0.D pfet_03v3 ad=0.44p pd=2.88u as=0.44p ps=2.88u w=1u l=1u
X541 x1.xtr.nfet_03v3_GP977X_0.S15 x1.pnp_05p00x05p00_0_0[0|0].E.t7 dvss.t30 ppolyf_u r_width=1u r_length=2.63u
X542 x1.xamp.vbn1 x1.xamp.vbn2 x1.xamp.vbn2 dvss.t316 nfet_03v3 ad=0.43415p pd=2.88u as=0.43415p ps=2.88u w=1u l=4u
X543 gf180mcu_ocd_ip__classab_buffer_0.se_folded_cascode_np_ab_0.outb1n gf180mcu_ocd_ip__classab_buffer_0.se_folded_cascode_np_ab_0.vbn1 dvss.t192 dvss.t201 nfet_03v3 ad=0.44p pd=2.88u as=0.44p ps=2.88u w=1u l=1u
X544 dvdd.t150 dvdd.t150 dvdd.t150 dvdd.t77 pfet_03v3 ad=0.87415p pd=4.88u as=0 ps=0 w=2u l=4u
X545 dvss.t24 dvss.t25 dvss.t23 ppolyf_u r_width=1u r_length=2.63u
X546 dvss.t24 dvss.t347 dvss.t23 ppolyf_u r_width=1u r_length=2.63u
X547 gf180mcu_ocd_ip__classab_buffer_0.se_folded_cascode_np_ab_0.outb1p gf180mcu_ocd_ip__classab_buffer_0.se_folded_cascode_np_ab_0.vbn2 gf180mcu_ocd_ip__classab_buffer_0.se_folded_cascode_np_ab_0.pfet_03v3_XWLNX2_0.D.t31 dvss.t398 nfet_03v3 ad=0.88p pd=4.88u as=0.88p ps=4.88u w=2u l=4u
X548 x1.xamp.pfet_03v3_EQVFPB_0.G1_0.t18 ibias1_250n x1.xamp.pfet_03v3_EQVFPB_0.S1_1 dvdd.t253 pfet_03v3 ad=0.86765p pd=4.88u as=0.86765p ps=4.88u w=2u l=0.5u
X549 dvss.t394 gf180mcu_ocd_ip__classab_buffer_0.se_folded_cascode_np_ab_0.vbn2 dvss.t394 dvss.t393 nfet_03v3 ad=0.88p pd=4.88u as=0 ps=0 w=2u l=4u
X550 gf180mcu_ocd_ip__classab_buffer_0.se_folded_cascode_np_ab_0.outb1n gf180mcu_ocd_ip__classab_buffer_0.se_folded_cascode_np_ab_0.vbn1 dvss.t180 dvss.t193 nfet_03v3 ad=0.44p pd=2.88u as=0.44p ps=2.88u w=1u l=1u
X551 dvdd.t163 dvdd.t161 dvdd.t163 dvdd.t164 pfet_03v3 ad=0.4257p pd=2.88u as=0 ps=0 w=1u l=0.5u
X552 x1.xamp.pfet_03v3_EQVFPB_0.G1_0.t2 x1.xamp.vbn2 x1.xamp.out1n dvss.t320 nfet_03v3 ad=0.43415p pd=2.88u as=0.43415p ps=2.88u w=1u l=4u
X553 x1.gf180mcu_as_sc_mcu7t3v3__buff_2_8.Y a_n8227_n22202# dvss.t6 dvss.t7 nfet_03v3 ad=0.26p pd=1.52u as=0.76p ps=3.52u w=1u l=0.28u
X554 a_n3700_n17319# a_n598_n17879# dvss.t34 ppolyf_u r_width=1u r_length=15u
X555 gf180mcu_ocd_ip__classab_buffer_0.se_folded_cascode_np_ab_0.outb1n gf180mcu_ocd_ip__classab_buffer_0.se_folded_cascode_np_ab_0.vbn2 gf180mcu_ocd_ip__classab_buffer_0.se_folded_cascode_np_ab_0.pfet_03v3_9TM96F_0.G0_0 dvss.t402 nfet_03v3 ad=0.88p pd=4.88u as=0.88p ps=4.88u w=2u l=4u
X556 dvdd.t242 x1.xamp.pfet_03v3_EQVFPB_0.G1_0.t32 x1.xamp.pfet_03v3_EQVFPB_0.S1_1 dvdd.t77 pfet_03v3 ad=0.87415p pd=4.88u as=0.87415p ps=4.88u w=2u l=4u
X557 x1.nfet_03v3_EV2W8D_0.S1.t9 ibias1_250n x1.xamp.pfet_03v3_EQVFPB_0.S1_0 dvdd.t253 pfet_03v3 ad=0.86765p pd=4.88u as=0.86765p ps=4.88u w=2u l=0.5u
X558 gf180mcu_ocd_ip__classab_buffer_0.se_folded_cascode_np_ab_0.outb1p gf180mcu_ocd_ip__classab_buffer_0.se_folded_cascode_np_ab_0.vbn2 gf180mcu_ocd_ip__classab_buffer_0.se_folded_cascode_np_ab_0.pfet_03v3_XWLNX2_0.D.t32 dvss.t400 nfet_03v3 ad=0.88p pd=4.88u as=0.88p ps=4.88u w=2u l=4u
X559 dvdd.t168 dvdd.t175 dvdd.t168 dvdd.t167 pfet_03v3 ad=0.44p pd=2.88u as=0 ps=0 w=1u l=4u
X560 dvss.t24 dvss.t24 x1.pnp_05p00x05p00_0_0[0|0].E pnp_05p00x05p00
**devattr s=1000000,4000 d=225453094,146072
X561 gf180mcu_ocd_ip__classab_buffer_0.se_folded_cascode_np_ab_0.outb1p gf180mcu_ocd_ip__classab_buffer_0.se_folded_cascode_np_ab_0.vbn2 gf180mcu_ocd_ip__classab_buffer_0.se_folded_cascode_np_ab_0.pfet_03v3_XWLNX2_0.D.t22 dvss.t396 nfet_03v3 ad=0.88p pd=4.88u as=0.88p ps=4.88u w=2u l=4u
X562 gf180mcu_ocd_ip__classab_buffer_0.se_folded_cascode_np_ab_0.nfet_03v3_XHQ8ZW_0.S0_0 gf180mcu_ocd_ip__classab_buffer_0.se_folded_cascode_np_ab_0.vbn1 dvss.t145 dvss.t70 nfet_03v3 ad=0.44p pd=2.88u as=0.44p ps=2.88u w=1u l=1u
X563 x1.nfet_03v3_EV2W8D_0.S1.t4 x1.xamp.vbn2 x1.xamp.out1p dvss.t321 nfet_03v3 ad=0.43415p pd=2.88u as=0.43415p ps=2.88u w=1u l=4u
X564 gf180mcu_ocd_ip__classab_buffer_0.se_folded_cascode_np_ab_0.outa1n.t29 gf180mcu_ocd_ip__classab_buffer_0.se_folded_cascode_np_ab_0.outa1n.t28 dvdd.t14 dvdd.t17 pfet_03v3 ad=0.44p pd=2.88u as=0.44p ps=2.88u w=1u l=1u
X565 gf180mcu_ocd_ip__classab_buffer_0.se_folded_cascode_np_ab_0.diffb x1.vbg gf180mcu_ocd_ip__classab_buffer_0.se_folded_cascode_np_ab_0.outb1p dvdd.t97 pfet_03v3 ad=1.76p pd=8.88u as=1.76p ps=8.88u w=4u l=1u
X566 gf180mcu_ocd_ip__classab_buffer_0.se_folded_cascode_np_ab_0.diffb gf180mcu_ocd_ip__classab_buffer_0.se_folded_cascode_np_ab_0.vbp1 dvdd.t42 dvdd.t43 pfet_03v3 ad=0.44p pd=2.88u as=0.44p ps=2.88u w=1u l=1u
X567 x1.xtr.nfet_03v3_GP977X_0.S3 x1.xtr.nfet_03v3_GP977X_0.S4 dvss.t27 ppolyf_u r_width=1u r_length=2.63u
X568 x1.xtr.nfet_03v3_GP977X_0.S3 x1.xtr.nfet_03v3_GP977X_0.S4 dvss.t27 ppolyf_u r_width=1u r_length=2.63u
X569 vbg gf180mcu_ocd_ip__classab_buffer_0.se_folded_cascode_np_ab_0.pfet_03v3_XWLNX2_0.D.t16 cap_mim_2f0_m4m5_noshield c_width=19u c_length=12u
X570 x1.gf180mcu_as_sc_mcu7t3v3__buff_2_11.Y a_n8227_n19514# dvss.t14 dvss.t298 nfet_03v3 ad=0.26p pd=1.52u as=0.76p ps=3.52u w=1u l=0.28u
X571 x1.xamp.out1p x1.xamp.vbn1 dvss.t63 dvss.t370 nfet_03v3 ad=0.43415p pd=2.88u as=0.43415p ps=2.88u w=1u l=1u
X572 gf180mcu_ocd_ip__classab_buffer_0.se_folded_cascode_np_ab_0.pfet_03v3_9TM96F_0.G0_0 gf180mcu_ocd_ip__classab_buffer_0.se_folded_cascode_np_ab_0.pfet_03v3_9TM96F_0.G0_0 gf180mcu_ocd_ip__classab_buffer_0.se_folded_cascode_np_ab_0.outa1n.t3 dvdd.t24 pfet_03v3 ad=0.44p pd=2.88u as=0.44p ps=2.88u w=1u l=4u
X573 x1.xamp.pfet_03v3_EQVFPB_0.G1_0.t16 ibias1_250n x1.xamp.pfet_03v3_EQVFPB_0.S1_1 dvdd.t253 pfet_03v3 ad=0.86765p pd=4.88u as=0.86765p ps=4.88u w=2u l=0.5u
X574 x1.nfet_03v3_EV2W8D_0.S1.t24 x1.nfet_03v3_EV2W8D_0.S0 dvss.t24 dvss.t3 nfet_03v3 ad=0.44p pd=2.88u as=0.44p ps=2.88u w=1u l=1u
X575 x1.xamp.out1n x1.xamp.vbn1 dvss.t83 dvss.t380 nfet_03v3 ad=0.43415p pd=2.88u as=0.43415p ps=2.88u w=1u l=1u
X576 gf180mcu_ocd_ip__classab_buffer_0.se_folded_cascode_np_ab_0.outb1n gf180mcu_ocd_ip__classab_buffer_0.se_folded_cascode_np_ab_0.vbn1 dvss.t171 dvss.t181 nfet_03v3 ad=0.44p pd=2.88u as=0.44p ps=2.88u w=1u l=1u
X577 x1.xtr.nfet_03v3_GP977X_0.S3 x1.gf180mcu_as_sc_mcu7t3v3__buff_2_12.Y x1.pnp_05p00x05p00_0_0[0|0].E.t28 dvss.t299 nfet_03v3 ad=1.2964p pd=7.08u as=1.2964p ps=7.08u w=3.1u l=0.28u
X578 gf180mcu_ocd_ip__classab_buffer_0.se_folded_cascode_np_ab_0.outb1n gf180mcu_ocd_ip__classab_buffer_0.se_folded_cascode_np_ab_0.vbn1 dvss.t180 dvss.t210 nfet_03v3 ad=0.44p pd=2.88u as=0.44p ps=2.88u w=1u l=1u
X579 a_n8227_n17722# trim[13] dvss.t291 dvss.t338 nfet_03v3 ad=0.44p pd=2.88u as=0.26p ps=1.52u w=1u l=0.28u
X580 dvdd.t114 gf180mcu_ocd_ip__classab_buffer_0.se_folded_cascode_np_ab_0.pfet_03v3_XWLNX2_0.D.t43 vbg dvdd.t31 pfet_03v3 ad=1.76p pd=8.88u as=1.76p ps=8.88u w=4u l=4u
X581 gf180mcu_ocd_ip__classab_buffer_0.se_folded_cascode_np_ab_0.outb1p gf180mcu_ocd_ip__classab_buffer_0.se_folded_cascode_np_ab_0.vbn1 dvss.t180 dvss.t208 nfet_03v3 ad=0.44p pd=2.88u as=0.44p ps=2.88u w=1u l=1u
X582 dvss.t279 x1.ena_buf gf180mcu_ocd_ip__classab_buffer_0.se_folded_cascode_np_ab_0.nfet_03v3_XRMCLC_0.S0_0 dvss.t284 nfet_03v3 ad=1.73465p pd=8.88u as=1.73465p ps=8.88u w=4u l=0.28u
X583 x1.xamp.pfet_03v3_VL4T3E_0.S1_0 x1.xamp.vbp1.t30 dvdd.t89 dvdd.t69 pfet_03v3 ad=0.44p pd=2.88u as=0.44p ps=2.88u w=1u l=1u
X584 gf180mcu_ocd_ip__classab_buffer_0.se_folded_cascode_np_ab_0.outb1p gf180mcu_ocd_ip__classab_buffer_0.se_folded_cascode_np_ab_0.vbn1 dvss.t180 dvss.t217 nfet_03v3 ad=0.44p pd=2.88u as=0.44p ps=2.88u w=1u l=1u
X585 gf180mcu_ocd_ip__classab_buffer_0.se_folded_cascode_np_ab_0.pfet_03v3_9TM96F_0.G0_0 gf180mcu_ocd_ip__classab_buffer_0.se_folded_cascode_np_ab_0.pfet_03v3_9TM96F_0.G0_0 gf180mcu_ocd_ip__classab_buffer_0.se_folded_cascode_np_ab_0.outa1n.t0 dvdd.t18 pfet_03v3 ad=0.44p pd=2.88u as=0.44p ps=2.88u w=1u l=4u
X586 gf180mcu_ocd_ip__classab_buffer_0.se_folded_cascode_np_ab_0.outb1n gf180mcu_ocd_ip__classab_buffer_0.se_folded_cascode_np_ab_0.vbn2 gf180mcu_ocd_ip__classab_buffer_0.se_folded_cascode_np_ab_0.pfet_03v3_9TM96F_0.G0_0 dvss.t398 nfet_03v3 ad=0.88p pd=4.88u as=0.88p ps=4.88u w=2u l=4u
X587 x1.xamp.pfet_03v3_VL4T3E_0.S1_0 x1.xamp.vbp1.t25 dvdd.t70 dvdd.t69 pfet_03v3 ad=0.44p pd=2.88u as=0.44p ps=2.88u w=1u l=1u
X588 gf180mcu_ocd_ip__classab_buffer_0.se_folded_cascode_np_ab_0.outb1p gf180mcu_ocd_ip__classab_buffer_0.se_folded_cascode_np_ab_0.vbn1 dvss.t192 dvss.t200 nfet_03v3 ad=0.44p pd=2.88u as=0.44p ps=2.88u w=1u l=1u
X589 x1.xtr.nfet_03v3_GP977X_0.S4 x1.xtr.nfet_03v3_GP977X_0.S5 dvss.t19 ppolyf_u r_width=1u r_length=2.63u
X590 x1.xtr.nfet_03v3_GP977X_0.S4 x1.xtr.nfet_03v3_GP977X_0.S5 dvss.t19 ppolyf_u r_width=1u r_length=2.63u
X591 gf180mcu_ocd_ip__classab_buffer_0.se_folded_cascode_np_ab_0.outa1p.t8 gf180mcu_ocd_ip__classab_buffer_0.se_folded_cascode_np_ab_0.pfet_03v3_9TM96F_0.G0_0 gf180mcu_ocd_ip__classab_buffer_0.se_folded_cascode_np_ab_0.pfet_03v3_XWLNX2_0.D.t0 dvdd.t22 pfet_03v3 ad=0.44p pd=2.88u as=0.44p ps=2.88u w=1u l=4u
X592 dvdd.t160 dvdd.t158 dvdd.t160 dvdd.t159 pfet_03v3 ad=0.4257p pd=2.88u as=0 ps=0 w=1u l=0.5u
X593 x1.xamp.pfet_03v3_EQVFPB_0.G1_0.t23 ibias1_250n x1.xamp.pfet_03v3_EQVFPB_0.S1_1 dvdd.t253 pfet_03v3 ad=0.86765p pd=4.88u as=0.86765p ps=4.88u w=2u l=0.5u
X594 x1.xamp.pfet_03v3_VL4T3E_0.S1_0 x1.xamp.vbp1.t20 dvdd.t70 dvdd.t69 pfet_03v3 ad=0.44p pd=2.88u as=0.44p ps=2.88u w=1u l=1u
X595 x1.gf180mcu_as_sc_mcu7t3v3__buff_2_7.Y a_n8227_n23322# dvss.t2 dvss.t3 nfet_03v3 ad=0.26p pd=1.52u as=0.76p ps=3.52u w=1u l=0.28u
X596 gf180mcu_ocd_ip__classab_buffer_0.se_folded_cascode_np_ab_0.vbp1 ibias2_1u ibias2_1u dvdd.t143 pfet_03v3 ad=0.4257p pd=2.88u as=0.4257p ps=2.88u w=1u l=0.5u
X597 a_n3700_n18439# a_n598_n18999# dvss.t37 ppolyf_u r_width=1u r_length=15u
X598 a_n3700_n20679# a_n598_n20119# dvss.t55 ppolyf_u r_width=1u r_length=15u
X599 x1.xamp.out1n x1.xamp.vbn1 dvss.t63 dvss.t372 nfet_03v3 ad=0.43415p pd=2.88u as=0.43415p ps=2.88u w=1u l=1u
X600 x1.xamp.out1n x1.xamp.inp x1.xamp.pfet_03v3_VL4T3E_0.S1_0 dvdd.t36 pfet_03v3 ad=1.76p pd=8.88u as=1.76p ps=8.88u w=4u l=1u
X601 dvss.t276 a_n8227_n15930# x1.gf180mcu_as_sc_mcu7t3v3__buff_2_15.Y dvss.t275 nfet_03v3 ad=0.26p pd=1.52u as=0.26p ps=1.52u w=1u l=0.28u
X602 x1.nfet_03v3_EV2W8D_0.S1.t1 x1.xamp.vbn2 x1.xamp.out1p dvss.t319 nfet_03v3 ad=0.43415p pd=2.88u as=0.43415p ps=2.88u w=1u l=4u
X603 gf180mcu_ocd_ip__classab_buffer_0.se_folded_cascode_np_ab_0.pfet_03v3_9TM96F_0.G0_0 gf180mcu_ocd_ip__classab_buffer_0.se_folded_cascode_np_ab_0.pfet_03v3_9TM96F_0.G0_0 gf180mcu_ocd_ip__classab_buffer_0.se_folded_cascode_np_ab_0.outa1n.t1 dvdd.t20 pfet_03v3 ad=0.44p pd=2.88u as=0.44p ps=2.88u w=1u l=4u
X604 dvss.t2 a_n8227_n24218# x1.gf180mcu_as_sc_mcu7t3v3__buff_2_6.Y dvss.t244 nfet_03v3 ad=0.26p pd=1.52u as=0.26p ps=1.52u w=1u l=0.28u
X605 x1.xamp.out1p x1.xamp.vbn1 dvss.t83 dvss.t382 nfet_03v3 ad=0.43415p pd=2.88u as=0.43415p ps=2.88u w=1u l=1u
X606 gf180mcu_ocd_ip__classab_buffer_0.se_folded_cascode_np_ab_0.outb1n gf180mcu_ocd_ip__classab_buffer_0.se_folded_cascode_np_ab_0.vbn2 gf180mcu_ocd_ip__classab_buffer_0.se_folded_cascode_np_ab_0.pfet_03v3_9TM96F_0.G0_0 dvss.t400 nfet_03v3 ad=0.88p pd=4.88u as=0.88p ps=4.88u w=2u l=4u
X607 x1.xamp.out1n x1.xamp.inp x1.xamp.pfet_03v3_VL4T3E_0.S1_0 dvdd.t34 pfet_03v3 ad=1.76p pd=8.88u as=1.76p ps=8.88u w=4u l=1u
X608 x1.xamp.vbn1 x1.xamp.vbn1 dvss.t79 dvss.t357 nfet_03v3 ad=0.43415p pd=2.88u as=0.43415p ps=2.88u w=1u l=1u
X609 x1.gf180mcu_as_sc_mcu7t3v3__buff_2_15.Y a_n8227_n15930# dvdd.t213 dvdd.t214 pfet_03v3 ad=0.3588p pd=1.9u as=1.0488p ps=4.28u w=1.38u l=0.28u
X610 x1.gf180mcu_as_sc_mcu7t3v3__buff_2_6.Y a_n8227_n24218# dvdd.t1 dvdd.t120 pfet_03v3 ad=0.3588p pd=1.9u as=1.0488p ps=4.28u w=1.38u l=0.28u
X611 x1.gf180mcu_as_sc_mcu7t3v3__buff_2_3.Y a_n8227_n26906# dvss.t257 dvss.t261 nfet_03v3 ad=0.26p pd=1.52u as=0.76p ps=3.52u w=1u l=0.28u
X612 dvss.t130 dvss.t128 dvss.t129 dvss.t84 nfet_03v3 ad=0.43415p pd=2.88u as=0 ps=0 w=1u l=1u
X613 dvdd.t168 dvdd.t191 dvdd.t168 dvdd.t167 pfet_03v3 ad=0.44p pd=2.88u as=0 ps=0 w=1u l=4u
X614 x1.xamp.out1p x1.xamp.vbn1 dvss.t112 dvss.t354 nfet_03v3 ad=0.43415p pd=2.88u as=0.43415p ps=2.88u w=1u l=1u
X615 dvdd.t281 x1.xamp.pfet_03v3_EQVFPB_0.G1_0.t26 x1.xamp.pfet_03v3_EQVFPB_0.S1_0 dvdd.t77 pfet_03v3 ad=0.87415p pd=4.88u as=0.87415p ps=4.88u w=2u l=4u
X616 x1.xamp.pfet_03v3_EQVFPB_0.G1_0.t21 ibias1_250n x1.xamp.pfet_03v3_EQVFPB_0.S1_1 dvdd.t253 pfet_03v3 ad=0.86765p pd=4.88u as=0.86765p ps=4.88u w=2u l=0.5u
X617 x1.xamp.pfet_03v3_VL4T3E_0.S1_0 x1.xamp.vbp1.t19 dvdd.t70 dvdd.t69 pfet_03v3 ad=0.44p pd=2.88u as=0.44p ps=2.88u w=1u l=1u
X618 x1.xtr.nfet_03v3_GP977X_0.S5 x1.gf180mcu_as_sc_mcu7t3v3__buff_2_10.Y x1.pnp_05p00x05p00_0_0[0|0].E.t3 dvss.t12 nfet_03v3 ad=1.2964p pd=7.08u as=1.2964p ps=7.08u w=3.1u l=0.28u
X619 gf180mcu_ocd_ip__classab_buffer_0.se_folded_cascode_np_ab_0.outb1p gf180mcu_ocd_ip__classab_buffer_0.se_folded_cascode_np_ab_0.vbn1 dvss.t180 dvss.t216 nfet_03v3 ad=0.44p pd=2.88u as=0.44p ps=2.88u w=1u l=1u
X620 dvdd.t160 dvdd.t161 dvdd.t163 dvdd.t162 pfet_03v3 ad=0.4257p pd=2.88u as=0 ps=0 w=1u l=0.5u
X621 gf180mcu_ocd_ip__classab_buffer_0.se_folded_cascode_np_ab_0.diffb gf180mcu_ocd_ip__classab_buffer_0.se_folded_cascode_np_ab_0.vbp1 dvdd.t42 dvdd.t41 pfet_03v3 ad=0.44p pd=2.88u as=0.44p ps=2.88u w=1u l=1u
X622 x1.nfet_03v3_EV2W8D_0.S1.t12 ibias1_250n x1.xamp.pfet_03v3_EQVFPB_0.S1_0 dvdd.t253 pfet_03v3 ad=0.86765p pd=4.88u as=0.86765p ps=4.88u w=2u l=0.5u
X623 dvss.t24 dvss.t24 x1.pnp_05p00x05p00_0_0[1|1].E pnp_05p00x05p00
**devattr s=1000000,4000 d=225453094,146072
X624 dvss.t86 dvss.t83 dvss.t85 dvss.t84 nfet_03v3 ad=0.43415p pd=2.88u as=0 ps=0 w=1u l=1u
X625 x1.xamp.out1p x1.xamp.vbn1 dvss.t112 dvss.t368 nfet_03v3 ad=0.43415p pd=2.88u as=0.43415p ps=2.88u w=1u l=1u
X626 x1.gf180mcu_as_sc_mcu7t3v3__buff_2_9.Y a_n8227_n21306# dvss.t10 dvss.t11 nfet_03v3 ad=0.26p pd=1.52u as=0.76p ps=3.52u w=1u l=0.28u
X627 x1.xtr.top x1.gf180mcu_as_sc_mcu7t3v3__buff_2_15.Y x1.pnp_05p00x05p00_0_0[0|0].E.t27 dvss.t296 nfet_03v3 ad=1.2964p pd=7.08u as=1.2964p ps=7.08u w=3.1u l=0.28u
X628 a_n3700_n19559# a_n598_n20119# dvss.t45 ppolyf_u r_width=1u r_length=15u
X629 x1.xamp.out1n x1.xamp.vbn1 dvss.t112 dvss.t355 nfet_03v3 ad=0.43415p pd=2.88u as=0.43415p ps=2.88u w=1u l=1u
X630 gf180mcu_ocd_ip__classab_buffer_0.se_folded_cascode_np_ab_0.outb1p gf180mcu_ocd_ip__classab_buffer_0.se_folded_cascode_np_ab_0.vbn1 dvss.t180 dvss.t211 nfet_03v3 ad=0.44p pd=2.88u as=0.44p ps=2.88u w=1u l=1u
X631 gf180mcu_ocd_ip__classab_buffer_0.se_folded_cascode_np_ab_0.outa1p.t16 gf180mcu_ocd_ip__classab_buffer_0.se_folded_cascode_np_ab_0.pfet_03v3_9TM96F_0.G0_0 gf180mcu_ocd_ip__classab_buffer_0.se_folded_cascode_np_ab_0.pfet_03v3_XWLNX2_0.D.t5 dvdd.t22 pfet_03v3 ad=0.44p pd=2.88u as=0.44p ps=2.88u w=1u l=4u
X632 dvdd.t160 dvdd.t158 dvdd.t160 dvdd.t159 pfet_03v3 ad=0.4257p pd=2.88u as=0 ps=0 w=1u l=0.5u
X633 x1.xamp.out1n x1.xamp.vbn1 dvss.t83 dvss.t378 nfet_03v3 ad=0.43415p pd=2.88u as=0.43415p ps=2.88u w=1u l=1u
X634 a_n3700_n21799# a_n598_n21239# dvss.t54 ppolyf_u r_width=1u r_length=15u
X635 x1.ena_buf a_n8227_n15034# dvss.t288 dvss.t289 nfet_03v3 ad=0.26p pd=1.52u as=0.76p ps=3.52u w=1u l=0.28u
X636 x1.xamp.out1p x1.xamp.vbn1 dvss.t83 dvss.t383 nfet_03v3 ad=0.43415p pd=2.88u as=0.43415p ps=2.88u w=1u l=1u
X637 gf180mcu_ocd_ip__classab_buffer_0.se_folded_cascode_np_ab_0.outb1n gf180mcu_ocd_ip__classab_buffer_0.se_folded_cascode_np_ab_0.vbn1 dvss.t180 dvss.t218 nfet_03v3 ad=0.44p pd=2.88u as=0.44p ps=2.88u w=1u l=1u
X638 x1.xamp.pfet_03v3_EQVFPB_0.G1_0.t19 ibias1_250n x1.xamp.pfet_03v3_EQVFPB_0.S1_1 dvdd.t253 pfet_03v3 ad=0.86765p pd=4.88u as=0.86765p ps=4.88u w=2u l=0.5u
X639 gf180mcu_ocd_ip__classab_buffer_0.se_folded_cascode_np_ab_0.nfet_03v3_XHQ8ZW_0.S0_0 gf180mcu_ocd_ip__classab_buffer_0.se_folded_cascode_np_ab_0.vbn1 dvss.t145 dvss.t68 nfet_03v3 ad=0.44p pd=2.88u as=0.44p ps=2.88u w=1u l=1u
X640 dvdd.t70 dvdd.t70 dvdd.t70 dvdd.t35 pfet_03v3 ad=1.76p pd=8.88u as=0 ps=0 w=4u l=1u
X641 gf180mcu_ocd_ip__classab_buffer_0.se_folded_cascode_np_ab_0.diffb gf180mcu_ocd_ip__classab_buffer_0.se_folded_cascode_np_ab_0.vbp1 dvdd.t42 dvdd.t46 pfet_03v3 ad=0.44p pd=2.88u as=0.44p ps=2.88u w=1u l=1u
X642 x1.nfet_03v3_EV2W8D_0.S1.t10 ibias1_250n x1.xamp.pfet_03v3_EQVFPB_0.S1_0 dvdd.t253 pfet_03v3 ad=0.86765p pd=4.88u as=0.86765p ps=4.88u w=2u l=0.5u
X643 x1.gf180mcu_as_sc_mcu7t3v3__buff_2_12.Y a_n8227_n18618# dvss.t291 dvss.t301 nfet_03v3 ad=0.26p pd=1.52u as=0.76p ps=3.52u w=1u l=0.28u
X644 x1.xamp.out1p x1.xamp.vbn1 dvss.t83 dvss.t376 nfet_03v3 ad=0.43415p pd=2.88u as=0.43415p ps=2.88u w=1u l=1u
X645 a_n8227_n16826# trim[14] dvss.t276 dvss.t344 nfet_03v3 ad=0.44p pd=2.88u as=0.26p ps=1.52u w=1u l=0.28u
X646 x1.pnp_05p00x05p00_0_0[0|0].E.t24 x1.pnp_05p00x05p00_0_0[0|0].E.t22 x1.pnp_05p00x05p00_0_0[0|0].E.t23 dvss.t46 nfet_03v3 ad=1.2964p pd=7.08u as=0 ps=0 w=3.1u l=0.28u
X647 gf180mcu_ocd_ip__classab_buffer_0.se_folded_cascode_np_ab_0.nfet_03v3_XHQ8ZW_0.S0_0 x1.vbg gf180mcu_ocd_ip__classab_buffer_0.se_folded_cascode_np_ab_0.outa1p.t27 dvss.t72 nfet_03v3 ad=0.88p pd=4.88u as=0.88p ps=4.88u w=2u l=1u
X648 gf180mcu_ocd_ip__classab_buffer_0.se_folded_cascode_np_ab_0.outa1p.t4 gf180mcu_ocd_ip__classab_buffer_0.se_folded_cascode_np_ab_0.pfet_03v3_9TM96F_0.G0_0 gf180mcu_ocd_ip__classab_buffer_0.se_folded_cascode_np_ab_0.pfet_03v3_XWLNX2_0.D.t12 dvdd.t23 pfet_03v3 ad=0.44p pd=2.88u as=0.44p ps=2.88u w=1u l=4u
X649 a_n8227_n22202# trim[8] dvdd.t4 dvdd.t129 pfet_03v3 ad=0.6072p pd=3.64u as=0.3588p ps=1.9u w=1.38u l=0.28u
X650 gf180mcu_ocd_ip__classab_buffer_0.se_folded_cascode_np_ab_0.diffb x1.vbg gf180mcu_ocd_ip__classab_buffer_0.se_folded_cascode_np_ab_0.outb1p dvdd.t100 pfet_03v3 ad=1.76p pd=8.88u as=1.76p ps=8.88u w=4u l=1u
X651 gf180mcu_ocd_ip__classab_buffer_0.se_folded_cascode_np_ab_0.diffb gf180mcu_ocd_ip__classab_buffer_0.se_folded_cascode_np_ab_0.vbp1 dvdd.t48 dvdd.t52 pfet_03v3 ad=0.44p pd=2.88u as=0.44p ps=2.88u w=1u l=1u
X652 x1.xamp.pfet_03v3_EQVFPB_0.G1_0.t17 ibias1_250n x1.xamp.pfet_03v3_EQVFPB_0.S1_1 dvdd.t253 pfet_03v3 ad=0.86765p pd=4.88u as=0.86765p ps=4.88u w=2u l=0.5u
X653 dvss.t305 dvss.t306 dvss.t304 ppolyf_u r_width=1u r_length=15u
X654 gf180mcu_ocd_ip__classab_buffer_0.se_folded_cascode_np_ab_0.outb1n gf180mcu_ocd_ip__classab_buffer_0.se_folded_cascode_np_ab_0.vbn1 dvss.t180 dvss.t179 nfet_03v3 ad=0.44p pd=2.88u as=0.44p ps=2.88u w=1u l=1u
X655 gf180mcu_ocd_ip__classab_buffer_0.se_folded_cascode_np_ab_0.nfet_03v3_XRMCLC_0.S0_0 gf180mcu_ocd_ip__classab_buffer_0.se_folded_cascode_np_ab_0.pfet_03v3_XWLNX2_0.D.t38 vbg dvss.t21 nfet_03v3 ad=1.76p pd=8.88u as=1.76p ps=8.88u w=4u l=4u
X656 x1.xamp.out1n x1.xamp.inp x1.xamp.pfet_03v3_VL4T3E_0.S1_0 dvdd.t36 pfet_03v3 ad=1.76p pd=8.88u as=1.76p ps=8.88u w=4u l=1u
X657 gf180mcu_ocd_ip__classab_buffer_0.se_folded_cascode_np_ab_0.vbp1 ibias2_1u ibias2_1u dvdd.t142 pfet_03v3 ad=0.4257p pd=2.88u as=0.4257p ps=2.88u w=1u l=0.5u
X658 x1.gf180mcu_as_sc_mcu7t3v3__buff_2_0.Y a_n8227_n29594# dvdd.t137 dvdd.t136 pfet_03v3 ad=0.3588p pd=1.9u as=1.0488p ps=4.28u w=1.38u l=0.28u
X659 gf180mcu_ocd_ip__classab_buffer_0.se_folded_cascode_np_ab_0.outa1p.t5 gf180mcu_ocd_ip__classab_buffer_0.se_folded_cascode_np_ab_0.pfet_03v3_9TM96F_0.G0_0 gf180mcu_ocd_ip__classab_buffer_0.se_folded_cascode_np_ab_0.pfet_03v3_XWLNX2_0.D.t3 dvdd.t25 pfet_03v3 ad=0.44p pd=2.88u as=0.44p ps=2.88u w=1u l=4u
X660 a_n8227_n27802# trim[2] dvdd.t131 dvdd.t262 pfet_03v3 ad=0.6072p pd=3.64u as=0.3588p ps=1.9u w=1.38u l=0.28u
X661 dvdd.t87 gf180mcu_ocd_ip__classab_buffer_0.se_folded_cascode_np_ab_0.pfet_03v3_XWLNX2_0.D.t42 vbg dvdd.t86 pfet_03v3 ad=1.76p pd=8.88u as=1.76p ps=8.88u w=4u l=4u
X662 gf180mcu_ocd_ip__classab_buffer_0.se_folded_cascode_np_ab_0.outb1p gf180mcu_ocd_ip__classab_buffer_0.se_folded_cascode_np_ab_0.vbn2 gf180mcu_ocd_ip__classab_buffer_0.se_folded_cascode_np_ab_0.pfet_03v3_XWLNX2_0.D.t37 dvss.t403 nfet_03v3 ad=0.88p pd=4.88u as=0.88p ps=4.88u w=2u l=4u
X663 dvdd.t163 dvdd.t161 dvdd.t163 dvdd.t164 pfet_03v3 ad=0.4257p pd=2.88u as=0 ps=0 w=1u l=0.5u
X664 dvss.t408 dvss.t409 dvss.t407 ppolyf_u r_width=1u r_length=15u
X665 x1.xamp.pfet_03v3_EQVFPB_0.G1_0.t15 ibias1_250n x1.xamp.pfet_03v3_EQVFPB_0.S1_1 dvdd.t253 pfet_03v3 ad=0.86765p pd=4.88u as=0.86765p ps=4.88u w=2u l=0.5u
X666 x1.xamp.vbn1 x1.xamp.vbn2 x1.xamp.vbn2 dvss.t317 nfet_03v3 ad=0.43415p pd=2.88u as=0.43415p ps=2.88u w=1u l=4u
X667 dvss.t145 dvss.t145 dvss.t145 dvss.t72 nfet_03v3 ad=0.44p pd=2.88u as=0 ps=0 w=1u l=1u
X668 x1.nfet_03v3_EV2W8D_0.S1.t25 dvss.t63 cap_mim_2f0_m4m5_noshield c_width=22u c_length=22u
X669 gf180mcu_ocd_ip__classab_buffer_0.se_folded_cascode_np_ab_0.nfet_03v3_XHQ8ZW_0.S0_0 vbg gf180mcu_ocd_ip__classab_buffer_0.se_folded_cascode_np_ab_0.outa1n.t40 dvss.t72 nfet_03v3 ad=0.88p pd=4.88u as=0.88p ps=4.88u w=2u l=1u
D27 trim[11] dvdd.t73 diode_pd2nw_03v3 pj=1.93u area=0.2295p
X670 x1.gf180mcu_as_sc_mcu7t3v3__buff_2_10.Y a_n8227_n20410# dvss.t14 dvss.t15 nfet_03v3 ad=0.26p pd=1.52u as=0.76p ps=3.52u w=1u l=0.28u
X671 gf180mcu_ocd_ip__classab_buffer_0.se_folded_cascode_np_ab_0.outa1p.t3 gf180mcu_ocd_ip__classab_buffer_0.se_folded_cascode_np_ab_0.pfet_03v3_9TM96F_0.G0_0 gf180mcu_ocd_ip__classab_buffer_0.se_folded_cascode_np_ab_0.pfet_03v3_XWLNX2_0.D.t11 dvdd.t21 pfet_03v3 ad=0.44p pd=2.88u as=0.44p ps=2.88u w=1u l=4u
X672 gf180mcu_ocd_ip__classab_buffer_0.se_folded_cascode_np_ab_0.pfet_03v3_9TM96F_0.G0_0 gf180mcu_ocd_ip__classab_buffer_0.se_folded_cascode_np_ab_0.pfet_03v3_9TM96F_0.G0_0 gf180mcu_ocd_ip__classab_buffer_0.se_folded_cascode_np_ab_0.outa1n.t11 dvdd.t24 pfet_03v3 ad=0.44p pd=2.88u as=0.44p ps=2.88u w=1u l=4u
X673 x1.xtr.top x1.xtr.top dvss.t39 ppolyf_u r_width=1u r_length=2.63u
X674 x1.xtr.top x1.xtr.top dvss.t39 ppolyf_u r_width=1u r_length=2.63u
X675 ibias1_250n ibias1_250n x1.xamp.vbp1.t10 dvdd.t251 pfet_03v3 ad=0.86765p pd=4.88u as=0.86765p ps=4.88u w=2u l=0.5u
X676 gf180mcu_ocd_ip__classab_buffer_0.se_folded_cascode_np_ab_0.outb1p gf180mcu_ocd_ip__classab_buffer_0.se_folded_cascode_np_ab_0.vbn2 gf180mcu_ocd_ip__classab_buffer_0.se_folded_cascode_np_ab_0.pfet_03v3_XWLNX2_0.D.t35 dvss.t399 nfet_03v3 ad=0.88p pd=4.88u as=0.88p ps=4.88u w=2u l=4u
X677 dvdd.t70 dvdd.t70 dvdd.t70 dvdd.t35 pfet_03v3 ad=1.76p pd=8.88u as=0 ps=0 w=4u l=1u
X678 dvdd.t245 x1.xamp.pfet_03v3_EQVFPB_0.G1_0.t35 x1.xamp.pfet_03v3_EQVFPB_0.S1_1 dvdd.t37 pfet_03v3 ad=0.87415p pd=4.88u as=0.87415p ps=4.88u w=2u l=4u
X679 gf180mcu_ocd_ip__classab_buffer_0.se_folded_cascode_np_ab_0.vbn1 gf180mcu_ocd_ip__classab_buffer_0.se_folded_cascode_np_ab_0.vbn1 dvss.t196 dvss.t175 nfet_03v3 ad=0.44p pd=2.88u as=0.44p ps=2.88u w=1u l=1u
X680 x1.xamp.out1n x1.xamp.inp x1.xamp.pfet_03v3_VL4T3E_0.S1_0 dvdd.t33 pfet_03v3 ad=1.76p pd=8.88u as=1.76p ps=8.88u w=4u l=1u
X681 gf180mcu_ocd_ip__classab_buffer_0.se_folded_cascode_np_ab_0.pfet_03v3_9TM96F_0.G0_0 gf180mcu_ocd_ip__classab_buffer_0.se_folded_cascode_np_ab_0.pfet_03v3_9TM96F_0.G0_0 gf180mcu_ocd_ip__classab_buffer_0.se_folded_cascode_np_ab_0.outa1n.t8 dvdd.t18 pfet_03v3 ad=0.44p pd=2.88u as=0.44p ps=2.88u w=1u l=4u
X682 x1.xtr.nfet_03v3_GP977X_0.S5 x1.xtr.nfet_03v3_GP977X_0.S6 dvss.t40 ppolyf_u r_width=1u r_length=2.63u
D28 dvss.t246 trim[10] diode_nd2ps_03v3 pj=1.83u area=0.209p
X683 x1.gf180mcu_as_sc_mcu7t3v3__buff_2_4.Y a_n8227_n26010# dvss.t242 dvss.t311 nfet_03v3 ad=0.26p pd=1.52u as=0.76p ps=3.52u w=1u l=0.28u
X684 x1.xtr.nfet_03v3_GP977X_0.S5 x1.xtr.nfet_03v3_GP977X_0.S6 dvss.t40 ppolyf_u r_width=1u r_length=2.63u
X685 gf180mcu_ocd_ip__classab_buffer_0.se_folded_cascode_np_ab_0.outb1n gf180mcu_ocd_ip__classab_buffer_0.se_folded_cascode_np_ab_0.vbn2 gf180mcu_ocd_ip__classab_buffer_0.se_folded_cascode_np_ab_0.pfet_03v3_9TM96F_0.G0_0 dvss.t403 nfet_03v3 ad=0.88p pd=4.88u as=0.88p ps=4.88u w=2u l=4u
X686 gf180mcu_ocd_ip__classab_buffer_0.se_folded_cascode_np_ab_0.outb1n gf180mcu_ocd_ip__classab_buffer_0.se_folded_cascode_np_ab_0.vbn1 dvss.t204 dvss.t205 nfet_03v3 ad=0.44p pd=2.88u as=0.44p ps=2.88u w=1u l=1u
X687 a_n8227_n15930# trim[15] dvss.t276 dvss.t335 nfet_03v3 ad=0.44p pd=2.88u as=0.26p ps=1.52u w=1u l=0.28u
X688 a_n8227_n19514# trim[11] dvdd.t76 dvdd.t75 pfet_03v3 ad=0.6072p pd=3.64u as=0.3588p ps=1.9u w=1.38u l=0.28u
X689 a_n3700_n16199# a_n598_n16759# dvss.t57 ppolyf_u r_width=1u r_length=15u
X690 dvdd.t210 x1.pfet_03v3_BWTVHK_0.D x1.nfet_03v3_EV2W8D_0.S0 dvdd.t209 pfet_03v3 ad=0.44p pd=2.88u as=0.44p ps=2.88u w=1u l=1u
X691 x1.xamp.pfet_03v3_EQVFPB_0.G1_0.t20 ibias1_250n x1.xamp.pfet_03v3_EQVFPB_0.S1_1 dvdd.t253 pfet_03v3 ad=0.86765p pd=4.88u as=0.86765p ps=4.88u w=2u l=0.5u
X692 gf180mcu_ocd_ip__classab_buffer_0.se_folded_cascode_np_ab_0.pfet_03v3_9TM96F_0.G0_0 gf180mcu_ocd_ip__classab_buffer_0.se_folded_cascode_np_ab_0.pfet_03v3_9TM96F_0.G0_0 gf180mcu_ocd_ip__classab_buffer_0.se_folded_cascode_np_ab_0.outa1n.t9 dvdd.t20 pfet_03v3 ad=0.44p pd=2.88u as=0.44p ps=2.88u w=1u l=4u
X693 x1.xtr.nfet_03v3_GP977X_0.S6 x1.xtr.nfet_03v3_GP977X_0.S7 dvss.t18 ppolyf_u r_width=1u r_length=2.63u
X694 x1.xtr.nfet_03v3_GP977X_0.S15 x1.pnp_05p00x05p00_0_0[0|0].E.t8 dvss.t30 ppolyf_u r_width=1u r_length=2.63u
X695 x1.xtr.nfet_03v3_GP977X_0.S6 x1.xtr.nfet_03v3_GP977X_0.S7 dvss.t18 ppolyf_u r_width=1u r_length=2.63u
X696 x1.xtr.nfet_03v3_GP977X_0.S15 x1.pnp_05p00x05p00_0_0[0|0].E.t9 dvss.t30 ppolyf_u r_width=1u r_length=2.63u
X697 a_n8227_n21306# trim[9] dvdd.t7 dvdd.t140 pfet_03v3 ad=0.6072p pd=3.64u as=0.3588p ps=1.9u w=1.38u l=0.28u
X698 gf180mcu_ocd_ip__classab_buffer_0.se_folded_cascode_np_ab_0.outb1n gf180mcu_ocd_ip__classab_buffer_0.se_folded_cascode_np_ab_0.vbn2 gf180mcu_ocd_ip__classab_buffer_0.se_folded_cascode_np_ab_0.pfet_03v3_9TM96F_0.G0_0 dvss.t401 nfet_03v3 ad=0.88p pd=4.88u as=0.88p ps=4.88u w=2u l=4u
X699 gf180mcu_ocd_ip__classab_buffer_0.se_folded_cascode_np_ab_0.diffb x1.vbg gf180mcu_ocd_ip__classab_buffer_0.se_folded_cascode_np_ab_0.outb1p dvdd.t98 pfet_03v3 ad=1.76p pd=8.88u as=1.76p ps=8.88u w=4u l=1u
X700 gf180mcu_ocd_ip__classab_buffer_0.se_folded_cascode_np_ab_0.outa1n.t31 gf180mcu_ocd_ip__classab_buffer_0.se_folded_cascode_np_ab_0.outa1n.t30 dvdd.t14 dvdd.t293 pfet_03v3 ad=0.44p pd=2.88u as=0.44p ps=2.88u w=1u l=1u
X701 gf180mcu_ocd_ip__classab_buffer_0.se_folded_cascode_np_ab_0.vbp1 ibias2_1u ibias2_1u dvdd.t141 pfet_03v3 ad=0.4257p pd=2.88u as=0.4257p ps=2.88u w=1u l=0.5u
X702 gf180mcu_ocd_ip__classab_buffer_0.se_folded_cascode_np_ab_0.outb1n gf180mcu_ocd_ip__classab_buffer_0.se_folded_cascode_np_ab_0.vbn1 dvss.t204 dvss.t207 nfet_03v3 ad=0.44p pd=2.88u as=0.44p ps=2.88u w=1u l=1u
X703 gf180mcu_ocd_ip__classab_buffer_0.se_folded_cascode_np_ab_0.vbp1 ibias2_1u ibias2_1u dvdd.t143 pfet_03v3 ad=0.4257p pd=2.88u as=0.4257p ps=2.88u w=1u l=0.5u
X704 a_n3700_n16479# x1.pnp_05p00x05p00_0_0[1|1].E dvss.t29 ppolyf_u r_width=1u r_length=15u
X705 gf180mcu_ocd_ip__classab_buffer_0.se_folded_cascode_np_ab_0.vbn2 gf180mcu_ocd_ip__classab_buffer_0.se_folded_cascode_np_ab_0.vbp1 dvdd.t48 dvdd.t54 pfet_03v3 ad=0.44p pd=2.88u as=0.44p ps=2.88u w=1u l=1u
X706 gf180mcu_ocd_ip__classab_buffer_0.se_folded_cascode_np_ab_0.outb1n gf180mcu_ocd_ip__classab_buffer_0.se_folded_cascode_np_ab_0.vbn2 gf180mcu_ocd_ip__classab_buffer_0.se_folded_cascode_np_ab_0.pfet_03v3_9TM96F_0.G0_0 dvss.t399 nfet_03v3 ad=0.88p pd=4.88u as=0.88p ps=4.88u w=2u l=4u
X707 x1.xamp.pfet_03v3_EQVFPB_0.G1_0.t22 ibias1_250n x1.xamp.pfet_03v3_EQVFPB_0.S1_1 dvdd.t253 pfet_03v3 ad=0.86765p pd=4.88u as=0.86765p ps=4.88u w=2u l=0.5u
X708 x1.gf180mcu_as_sc_mcu7t3v3__buff_2_1.Y a_n8227_n28698# dvdd.t81 dvdd.t82 pfet_03v3 ad=0.3588p pd=1.9u as=1.0488p ps=4.28u w=1.38u l=0.28u
X709 x1.xamp.pfet_03v3_VL4T3E_0.S1_0 x1.xamp.vbp1.t31 dvdd.t89 dvdd.t69 pfet_03v3 ad=0.44p pd=2.88u as=0.44p ps=2.88u w=1u l=1u
X710 x1.xtr.nfet_03v3_GP977X_0.S10 x1.gf180mcu_as_sc_mcu7t3v3__buff_2_5.Y x1.pnp_05p00x05p00_0_0[0|0].E.t31 dvss.t312 nfet_03v3 ad=1.2964p pd=7.08u as=1.2964p ps=7.08u w=3.1u l=0.28u
X711 x1.xtr.nfet_03v3_GP977X_0.S7 x1.xtr.nfet_03v3_GP977X_0.S8 dvss.t32 ppolyf_u r_width=1u r_length=2.63u
X712 x1.xtr.nfet_03v3_GP977X_0.S7 x1.xtr.nfet_03v3_GP977X_0.S8 dvss.t32 ppolyf_u r_width=1u r_length=2.63u
X713 x1.xtr.nfet_03v3_GP977X_0.S7 x1.gf180mcu_as_sc_mcu7t3v3__buff_2_8.Y x1.pnp_05p00x05p00_0_0[0|0].E.t1 dvss.t4 nfet_03v3 ad=1.2964p pd=7.08u as=1.2964p ps=7.08u w=3.1u l=0.28u
X714 dvss.t24 dvss.t24 x1.pnp_05p00x05p00_0_0[0|0].E pnp_05p00x05p00
**devattr s=1000000,4000 d=225453094,146072
X715 a_n8227_n26906# trim[3] dvdd.t131 dvdd.t146 pfet_03v3 ad=0.6072p pd=3.64u as=0.3588p ps=1.9u w=1.38u l=0.28u
X716 gf180mcu_ocd_ip__classab_buffer_0.se_folded_cascode_np_ab_0.outb1n gf180mcu_ocd_ip__classab_buffer_0.se_folded_cascode_np_ab_0.vbn1 dvss.t192 dvss.t191 nfet_03v3 ad=0.44p pd=2.88u as=0.44p ps=2.88u w=1u l=1u
X717 gf180mcu_ocd_ip__classab_buffer_0.se_folded_cascode_np_ab_0.nfet_03v3_XHQ8ZW_0.S0_0 x1.vbg gf180mcu_ocd_ip__classab_buffer_0.se_folded_cascode_np_ab_0.outa1p.t30 dvss.t75 nfet_03v3 ad=0.88p pd=4.88u as=0.88p ps=4.88u w=2u l=1u
D29 trim[9] dvdd.t138 diode_pd2nw_03v3 pj=1.93u area=0.2295p
X718 gf180mcu_ocd_ip__classab_buffer_0.se_folded_cascode_np_ab_0.nfet_03v3_XRMCLC_0.S0_0 gf180mcu_ocd_ip__classab_buffer_0.se_folded_cascode_np_ab_0.pfet_03v3_XWLNX2_0.D.t39 vbg dvss.t66 nfet_03v3 ad=1.76p pd=8.88u as=1.76p ps=8.88u w=4u l=4u
X719 gf180mcu_ocd_ip__classab_buffer_0.se_folded_cascode_np_ab_0.outb1p gf180mcu_ocd_ip__classab_buffer_0.se_folded_cascode_np_ab_0.vbn2 gf180mcu_ocd_ip__classab_buffer_0.se_folded_cascode_np_ab_0.pfet_03v3_XWLNX2_0.D.t29 dvss.t403 nfet_03v3 ad=0.88p pd=4.88u as=0.88p ps=4.88u w=2u l=4u
D30 ena dvdd.t270 diode_pd2nw_03v3 pj=1.93u area=0.2295p
X720 gf180mcu_ocd_ip__classab_buffer_0.se_folded_cascode_np_ab_0.outb1n gf180mcu_ocd_ip__classab_buffer_0.se_folded_cascode_np_ab_0.vbn1 dvss.t180 dvss.t215 nfet_03v3 ad=0.44p pd=2.88u as=0.44p ps=2.88u w=1u l=1u
X721 gf180mcu_ocd_ip__classab_buffer_0.se_folded_cascode_np_ab_0.outb1n gf180mcu_ocd_ip__classab_buffer_0.se_folded_cascode_np_ab_0.vbn2 gf180mcu_ocd_ip__classab_buffer_0.se_folded_cascode_np_ab_0.pfet_03v3_9TM96F_0.G0_0 dvss.t397 nfet_03v3 ad=0.88p pd=4.88u as=0.88p ps=4.88u w=2u l=4u
X722 x1.xamp.pfet_03v3_VL4T3E_0.S1_0 x1.xamp.vbp1.t29 dvdd.t70 dvdd.t69 pfet_03v3 ad=0.44p pd=2.88u as=0.44p ps=2.88u w=1u l=1u
X723 gf180mcu_ocd_ip__classab_buffer_0.se_folded_cascode_np_ab_0.vbn1 gf180mcu_ocd_ip__classab_buffer_0.se_folded_cascode_np_ab_0.vbn1 dvss.t171 dvss.t177 nfet_03v3 ad=0.44p pd=2.88u as=0.44p ps=2.88u w=1u l=1u
X724 x1.xamp.pfet_03v3_VL4T3E_0.S1_0 x1.xamp.vbp1.t24 dvdd.t70 dvdd.t69 pfet_03v3 ad=0.44p pd=2.88u as=0.44p ps=2.88u w=1u l=1u
X725 gf180mcu_ocd_ip__classab_buffer_0.se_folded_cascode_np_ab_0.outb1p gf180mcu_ocd_ip__classab_buffer_0.se_folded_cascode_np_ab_0.vbn1 dvss.t204 dvss.t206 nfet_03v3 ad=0.44p pd=2.88u as=0.44p ps=2.88u w=1u l=1u
D31 dvss.t252 trim[8] diode_nd2ps_03v3 pj=1.83u area=0.209p
D32 trim[3] dvdd.t144 diode_pd2nw_03v3 pj=1.93u area=0.2295p
D33 dvss.t333 trim[15] diode_nd2ps_03v3 pj=1.83u area=0.209p
X726 x1.xamp.out1p x1.xamp.vbn1 dvss.t83 dvss.t374 nfet_03v3 ad=0.43415p pd=2.88u as=0.43415p ps=2.88u w=1u l=1u
X727 dvss.t279 x1.ena_buf gf180mcu_ocd_ip__classab_buffer_0.se_folded_cascode_np_ab_0.nfet_03v3_XRMCLC_0.S0_0 dvss.t280 nfet_03v3 ad=1.73465p pd=8.88u as=1.73465p ps=8.88u w=4u l=0.28u
X728 gf180mcu_ocd_ip__classab_buffer_0.se_folded_cascode_np_ab_0.outb1p gf180mcu_ocd_ip__classab_buffer_0.se_folded_cascode_np_ab_0.vbn2 gf180mcu_ocd_ip__classab_buffer_0.se_folded_cascode_np_ab_0.pfet_03v3_XWLNX2_0.D.t27 dvss.t399 nfet_03v3 ad=0.88p pd=4.88u as=0.88p ps=4.88u w=2u l=4u
X729 gf180mcu_ocd_ip__classab_buffer_0.se_folded_cascode_np_ab_0.outa1p.t22 gf180mcu_ocd_ip__classab_buffer_0.se_folded_cascode_np_ab_0.outa1n.t48 dvdd.t14 dvdd.t79 pfet_03v3 ad=0.44p pd=2.88u as=0.44p ps=2.88u w=1u l=1u
X730 x1.xamp.out1n x1.xamp.vbn1 dvss.t83 dvss.t382 nfet_03v3 ad=0.43415p pd=2.88u as=0.43415p ps=2.88u w=1u l=1u
X731 vbg gf180mcu_ocd_ip__classab_buffer_0.se_folded_cascode_np_ab_0.pfet_03v3_XWLNX2_0.D.t16 cap_mim_2f0_m4m5_noshield c_width=19u c_length=12u
X732 gf180mcu_ocd_ip__classab_buffer_0.se_folded_cascode_np_ab_0.outa1n.t35 gf180mcu_ocd_ip__classab_buffer_0.se_folded_cascode_np_ab_0.outa1n.t34 dvdd.t14 dvdd.t28 pfet_03v3 ad=0.44p pd=2.88u as=0.44p ps=2.88u w=1u l=1u
R0 dvdd.n72 dvdd.n7 488479
R1 dvdd.t54 dvdd.n63 95754.7
R2 dvdd.n120 dvdd.n119 9984
R3 dvdd.n42 dvdd.n75 1669.73
R4 dvdd.t14 dvdd.n0 782.317
R5 dvdd.t14 dvdd.n62 758.903
R6 dvdd.t231 dvdd.t82 637.597
R7 dvdd.t124 dvdd.t132 637.597
R8 dvdd.t260 dvdd.t134 637.597
R9 dvdd.t144 dvdd.t235 637.597
R10 dvdd.t239 dvdd.t118 637.597
R11 dvdd.t246 dvdd.t120 637.597
R12 dvdd.t287 dvdd.t2 637.597
R13 dvdd.t127 dvdd.t8 637.597
R14 dvdd.t138 dvdd.t10 637.597
R15 dvdd.t121 dvdd.t228 637.597
R16 dvdd.t73 dvdd.t230 637.597
R17 dvdd.t276 dvdd.t224 637.597
R18 dvdd.t267 dvdd.t226 637.597
R19 dvdd.t273 dvdd.t214 637.597
R20 dvdd.t264 dvdd.t221 637.597
R21 dvdd.t137 dvdd.t136 630.543
R22 dvdd.n82 dvdd.t5 625.97
R23 dvdd.n52 dvdd.n29 1.37099
R24 dvdd.n50 dvdd.n28 2.89472
R25 dvdd.n50 dvdd.n11 2.76599
R26 dvdd.n78 dvdd.n53 0.368306
R27 dvdd.n9 dvdd.n41 507.43
R28 dvdd.t233 dvdd.t231 478.683
R29 dvdd.t126 dvdd.t124 478.683
R30 dvdd.t262 dvdd.t260 478.683
R31 dvdd.t146 dvdd.t144 478.683
R32 dvdd.t241 dvdd.t239 478.683
R33 dvdd.t248 dvdd.t246 478.683
R34 dvdd.t289 dvdd.t287 478.683
R35 dvdd.t238 dvdd.t236 478.683
R36 dvdd.t129 dvdd.t127 478.683
R37 dvdd.t140 dvdd.t138 478.683
R38 dvdd.t123 dvdd.t121 478.683
R39 dvdd.t75 dvdd.t73 478.683
R40 dvdd.t278 dvdd.t276 478.683
R41 dvdd.t269 dvdd.t267 478.683
R42 dvdd.t275 dvdd.t273 478.683
R43 dvdd.t266 dvdd.t264 478.683
R44 dvdd.t272 dvdd.t270 478.683
R45 dvdd.n81 dvdd.t270 450.139
R46 dvdd.t236 dvdd.n82 445.736
R47 dvdd.n42 dvdd.n55 399.611
R48 dvdd.t70 dvdd.n30 311.092
R49 dvdd.t136 dvdd.t135 310.079
R50 dvdd.t135 dvdd.t233 310.079
R51 dvdd.t82 dvdd.t80 310.079
R52 dvdd.t80 dvdd.t126 310.079
R53 dvdd.t132 dvdd.t130 310.079
R54 dvdd.t130 dvdd.t262 310.079
R55 dvdd.t134 dvdd.t133 310.079
R56 dvdd.t133 dvdd.t146 310.079
R57 dvdd.t235 dvdd.t234 310.079
R58 dvdd.t234 dvdd.t241 310.079
R59 dvdd.t118 dvdd.t116 310.079
R60 dvdd.t116 dvdd.t248 310.079
R61 dvdd.t120 dvdd.t119 310.079
R62 dvdd.t119 dvdd.t289 310.079
R63 dvdd.t2 dvdd.t0 310.079
R64 dvdd.t0 dvdd.t238 310.079
R65 dvdd.t5 dvdd.t3 310.079
R66 dvdd.t3 dvdd.t129 310.079
R67 dvdd.t8 dvdd.t6 310.079
R68 dvdd.t6 dvdd.t140 310.079
R69 dvdd.t10 dvdd.t9 310.079
R70 dvdd.t9 dvdd.t123 310.079
R71 dvdd.t228 dvdd.t227 310.079
R72 dvdd.t227 dvdd.t75 310.079
R73 dvdd.t230 dvdd.t229 310.079
R74 dvdd.t229 dvdd.t278 310.079
R75 dvdd.t224 dvdd.t222 310.079
R76 dvdd.t222 dvdd.t269 310.079
R77 dvdd.t226 dvdd.t225 310.079
R78 dvdd.t225 dvdd.t275 310.079
R79 dvdd.t214 dvdd.t212 310.079
R80 dvdd.t212 dvdd.t266 310.079
R81 dvdd.t221 dvdd.t220 310.079
R82 dvdd.t220 dvdd.t272 310.079
R83 dvdd.n118 dvdd.n39 0.190335
R84 dvdd.t33 dvdd.t35 302.019
R85 dvdd.t36 dvdd.t34 302.019
R86 dvdd.n118 dvdd.n117 301.923
R87 dvdd.t147 dvdd.t298 280.329
R88 dvdd.t259 dvdd.t106 280.329
R89 dvdd.n4 dvdd.n2 2.90302
R90 dvdd.n23 dvdd.n21 249.608
R91 dvdd.n20 dvdd.n21 0.251071
R92 dvdd.n118 dvdd.t33 249.24
R93 dvdd.n19 dvdd.n64 0.501396
R94 dvdd.n23 dvdd.n19 1.81344
R95 dvdd.t218 dvdd.n72 219.826
R96 dvdd.n37 dvdd.n0 1.56281
R97 dvdd.t70 dvdd.t36 215.585
R98 dvdd.n71 dvdd.n10 0.240886
R99 dvdd.n71 dvdd.n68 212.536
R100 dvdd.t298 dvdd.n90 197.351
R101 dvdd.n84 dvdd.t259 197.351
R102 dvdd.n37 dvdd.n35 166.672
R103 dvdd.t34 dvdd.n121 165.643
R104 dvdd.n73 dvdd.t86 140.233
R105 dvdd.n91 dvdd.t147 140.165
R106 dvdd.t106 dvdd.n91 140.165
R107 dvdd.t79 dvdd.n74 134.695
R108 dvdd.n7 dvdd.n9 130.865
R109 dvdd.t61 dvdd.t60 130.613
R110 dvdd.t26 dvdd.t61 130.613
R111 dvdd.t11 dvdd.t71 130.613
R112 dvdd.t15 dvdd.t292 130.613
R113 dvdd.t40 dvdd.t29 130.613
R114 dvdd.t284 dvdd.t280 130.613
R115 dvdd.t17 dvdd.t284 130.613
R116 dvdd.t293 dvdd.t30 130.613
R117 dvdd.t279 dvdd.t282 130.613
R118 dvdd.t28 dvdd.t39 130.613
R119 dvdd.t286 dvdd.t28 130.613
R120 dvdd.t13 dvdd.t285 130.613
R121 dvdd.t59 dvdd.t164 125.948
R122 dvdd.n24 dvdd.t72 120.118
R123 dvdd.n41 dvdd.t27 114.578
R124 dvdd.t27 dvdd.t20 111.954
R125 dvdd.n84 dvdd.n86 110.864
R126 dvdd.n84 dvdd.n85 110.864
R127 dvdd.n90 dvdd.n85 110.864
R128 dvdd.n90 dvdd.n86 110.864
R129 dvdd.t30 dvdd.t23 109.621
R130 dvdd.t25 dvdd.t279 109.621
R131 dvdd.t22 dvdd.t40 107.29
R132 dvdd.t285 dvdd.t167 107.29
R133 dvdd.t35 dvdd.n80 106.526
R134 dvdd.t19 dvdd.t11 104.957
R135 dvdd.t72 dvdd.t31 103.79
R136 dvdd.n68 dvdd.n55 103.272
R137 dvdd.t143 dvdd.t142 99.709
R138 dvdd.n25 dvdd.n55 99.1258
R139 dvdd.t41 dvdd.t101 96.5826
R140 dvdd.t43 dvdd.t98 96.5826
R141 dvdd.t44 dvdd.t102 96.5826
R142 dvdd.t103 dvdd.t46 96.5826
R143 dvdd.t100 dvdd.t47 96.5826
R144 dvdd.t104 dvdd.t49 96.5826
R145 dvdd.t50 dvdd.t162 95.0442
R146 dvdd.t14 dvdd.t290 93.8781
R147 dvdd.t58 dvdd.t141 82.5078
R148 dvdd.n65 dvdd.t97 76.9575
R149 dvdd.n64 dvdd.t52 75.6345
R150 dvdd.t71 dvdd.t18 69.9713
R151 dvdd.n78 dvdd.n35 69.3624
R152 dvdd.t29 dvdd.t21 67.639
R153 dvdd.n25 dvdd.n9 67.2271
R154 dvdd.t159 dvdd.t55 66.4728
R155 dvdd.t24 dvdd.t293 65.3066
R156 dvdd.t282 dvdd.t24 65.3066
R157 dvdd.t57 dvdd.t159 64.1404
R158 dvdd.n87 dvdd.n40 63.0005
R159 dvdd.n33 dvdd.n88 1.81053
R160 dvdd.t21 dvdd.t291 62.9743
R161 dvdd.t18 dvdd.t26 60.6419
R162 dvdd.n52 dvdd.n2 0.457477
R163 dvdd.t249 dvdd.t253 52.1115
R164 dvdd.n33 dvdd.n89 51.8312
R165 dvdd.n88 dvdd.n87 51.0717
R166 dvdd.t141 dvdd.t59 48.1055
R167 dvdd.t45 dvdd.n22 46.748
R168 dvdd.n36 dvdd.n66 45.866
R169 dvdd.t14 dvdd.t292 36.7352
R170 dvdd.t162 dvdd.t57 35.569
R171 dvdd.n68 dvdd.n62 35.438
R172 dvdd.n29 dvdd.n1 0.65866
R173 dvdd.t55 dvdd.n79 33.8197
R174 dvdd.n119 dvdd.t37 30.5025
R175 dvdd.t216 dvdd.n50 30.304
R176 dvdd.t251 dvdd.t77 28.5078
R177 dvdd.t69 dvdd.n52 28.392
R178 dvdd.n4 dvdd.t252 28.2585
R179 dvdd.t31 dvdd.t79 26.8227
R180 dvdd.t290 dvdd.t19 25.6565
R181 dvdd.t167 dvdd.t286 23.3241
R182 dvdd.t86 dvdd.t218 22.4495
R183 dvdd.t23 dvdd.t17 20.9918
R184 dvdd.t39 dvdd.t25 20.9918
R185 dvdd.n120 dvdd.n80 19.6083
R186 dvdd.t20 dvdd.t15 18.6594
R187 dvdd.t142 dvdd.t58 17.2017
R188 dvdd.t291 dvdd.n41 16.0355
R189 dvdd.n4 dvdd.t251 14.2957
R190 dvdd.t77 dvdd.t250 14.0464
R191 dvdd.n75 dvdd.n35 13.8069
R192 dvdd.t60 dvdd.t143 13.7031
R193 dvdd.t280 dvdd.n42 13.7031
R194 dvdd.n76 dvdd.n54 13.6789
R195 dvdd.t215 dvdd.t54 13.6719
R196 dvdd.n24 dvdd.t13 10.4961
R197 dvdd.n42 dvdd.t22 9.62149
R198 dvdd.n64 dvdd.t215 9.48231
R199 dvdd.t253 dvdd.t216 8.31167
R200 dvdd.n30 dvdd.n120 8.19482
R201 dvdd.t250 dvdd.t70 7.23122
R202 dvdd.t166 dvdd.n16 1.1972
R203 dvdd.t175 dvdd.t168 3.47723
R204 dvdd.t183 dvdd.t168 3.49753
R205 dvdd.n17 dvdd.t191 1.19679
R206 dvdd.n27 dvdd.t38 6.6427
R207 dvdd.n95 dvdd.t295 6.43214
R208 dvdd.n117 dvdd.n80 6.3005
R209 dvdd.n117 dvdd.n31 3.40842
R210 dvdd.t281 dvdd.n15 5.8415
R211 dvdd.n42 dvdd.t161 5.65352
R212 dvdd.t263 dvdd.n15 5.49868
R213 dvdd.n105 dvdd.t294 5.45964
R214 dvdd.n112 dvdd.n48 5.30543
R215 dvdd.n111 dvdd.n110 5.30289
R216 dvdd.n106 dvdd.n93 5.30163
R217 dvdd.n4 dvdd.t258 5.30163
R218 dvdd.t38 dvdd.n26 5.30163
R219 dvdd.n44 dvdd.n12 5.293
R220 dvdd.n100 dvdd.n4 5.293
R221 dvdd.t297 dvdd.n105 5.29275
R222 dvdd.t245 dvdd.n109 5.29275
R223 dvdd.t283 dvdd.n99 5.29175
R224 dvdd.n97 dvdd.n14 5.29175
R225 dvdd.t295 dvdd.n13 5.288
R226 dvdd.n101 dvdd.t243 5.28675
R227 dvdd.t252 dvdd.t69 4.90409
R228 dvdd.n27 dvdd.t148 4.88364
R229 dvdd.t161 dvdd.t163 4.82773
R230 dvdd.t158 dvdd.t160 4.82577
R231 dvdd.t168 dvdd.n17 2.31255
R232 dvdd.t164 dvdd.t50 4.66522
R233 dvdd.n94 dvdd.t88 4.5543
R234 dvdd.t296 dvdd.n95 4.5005
R235 dvdd.n102 dvdd.n101 4.5005
R236 dvdd.t281 dvdd.n14 4.5005
R237 dvdd.n99 dvdd.n98 4.5005
R238 dvdd.t105 dvdd.n4 4.5005
R239 dvdd.n44 dvdd.t244 4.5005
R240 dvdd.n96 dvdd.n13 4.5005
R241 dvdd.n110 dvdd.t242 4.5005
R242 dvdd.n114 dvdd.n26 4.5005
R243 dvdd.t78 dvdd.n48 4.5005
R244 dvdd.n113 dvdd.n4 4.5005
R245 dvdd.n109 dvdd.n108 4.5005
R246 dvdd.n107 dvdd.n106 4.5005
R247 dvdd.t4 dvdd.n82 4.39903
R248 dvdd.n83 dvdd.n81 4.16737
R249 dvdd.t37 dvdd.t249 4.07297
R250 dvdd.n74 dvdd.n73 3.79059
R251 dvdd.n42 dvdd.n54 3.61035
R252 dvdd.n53 dvdd.n41 3.57807
R253 dvdd.n83 dvdd.n59 3.28903
R254 dvdd.n28 dvdd.t217 0.003541
R255 dvdd.n15 dvdd.n47 0.513199
R256 dvdd.n11 dvdd.n31 0.00294944
R257 dvdd.n41 dvdd.n77 2.77507
R258 dvdd.n79 dvdd.n63 2.62441
R259 dvdd.n16 dvdd.t168 2.56928
R260 dvdd.n74 dvdd.n7 2.51939
R261 dvdd.n39 dvdd.n38 2.3667
R262 dvdd.n4 dvdd.n116 2.2505
R263 dvdd.n115 dvdd.n49 2.2505
R264 dvdd.n94 dvdd.t150 2.2505
R265 dvdd.n46 dvdd.n104 2.2505
R266 dvdd.n103 dvdd.n45 2.2505
R267 dvdd.n3 dvdd.n56 2.2505
R268 dvdd.t97 dvdd.t41 2.20557
R269 dvdd.t101 dvdd.t43 2.20557
R270 dvdd.t98 dvdd.t44 2.20557
R271 dvdd.t102 dvdd.t45 2.20557
R272 dvdd.n36 dvdd.t99 2.20557
R273 dvdd.t46 dvdd.t99 2.20557
R274 dvdd.t47 dvdd.t103 2.20557
R275 dvdd.t49 dvdd.t100 2.20557
R276 dvdd.t52 dvdd.t104 2.20557
R277 dvdd.n75 dvdd.n63 2.1005
R278 dvdd.n75 dvdd.n57 2.1005
R279 dvdd.n121 dvdd.n30 2.04908
R280 dvdd.n21 dvdd.n65 2.01656
R281 dvdd.n31 dvdd.n39 1.9802
R282 dvdd.n10 dvdd.n7 1.91394
R283 dvdd.n6 dvdd.n60 1.77383
R284 dvdd.n66 dvdd.n22 1.76456
R285 dvdd.n18 dvdd.n19 1.73661
R286 dvdd.n6 dvdd.n61 1.70618
R287 dvdd.n18 dvdd.n20 1.65926
R288 dvdd.t210 dvdd.n33 0.0199759
R289 dvdd.t299 dvdd.n40 1.5755
R290 dvdd.n76 dvdd.n67 1.56267
R291 dvdd.t70 dvdd.n38 1.50512
R292 dvdd.n58 dvdd.n37 1.95708
R293 dvdd.n4 dvdd.n3 1.86488
R294 dvdd.n61 dvdd.t114 1.47874
R295 dvdd.n92 dvdd.n32 1.4529
R296 dvdd.t87 dvdd.n60 1.41558
R297 dvdd dvdd.n122 1.40456
R298 dvdd.n96 dvdd.t296 1.34793
R299 dvdd.n108 dvdd.n107 1.34793
R300 dvdd.n93 dvdd.t245 1.34793
R301 dvdd.t258 dvdd.n112 1.34664
R302 dvdd.t243 dvdd.n100 1.34536
R303 dvdd.t213 dvdd.t223 1.3445
R304 dvdd.t223 dvdd.t76 1.3445
R305 dvdd.t76 dvdd.t7 1.3445
R306 dvdd.t1 dvdd.t117 1.3445
R307 dvdd.t117 dvdd.t131 1.3445
R308 dvdd.t131 dvdd.t81 1.3445
R309 dvdd.n114 dvdd.t78 1.34279
R310 dvdd.n98 dvdd.t105 1.3415
R311 dvdd.t244 dvdd.n102 1.3415
R312 dvdd.t258 dvdd.n111 1.34021
R313 dvdd.n113 dvdd.t242 1.33893
R314 dvdd.t78 dvdd.n113 1.33893
R315 dvdd.n108 dvdd.t242 1.33507
R316 dvdd.t283 dvdd.n97 1.33379
R317 dvdd.n111 dvdd.t245 1.3325
R318 dvdd.n93 dvdd.t297 1.3325
R319 dvdd.n112 dvdd.t38 1.3325
R320 dvdd.n15 dvdd.t154 1.33182
R321 dvdd dvdd.n59 1.28851
R322 dvdd.n51 dvdd.n92 1.28159
R323 dvdd.t51 dvdd.t12 1.2805
R324 dvdd.t12 dvdd.t16 1.2805
R325 dvdd.t16 dvdd.t14 1.2805
R326 dvdd.t209 dvdd.n88 1.27777
R327 dvdd.n89 dvdd.t209 1.27777
R328 dvdd.n61 dvdd.t32 1.19224
R329 dvdd.t42 dvdd.t48 1.16086
R330 dvdd.n69 dvdd.n67 1.14744
R331 dvdd.n97 dvdd.t263 1.14736
R332 dvdd.n0 dvdd.n23 1.1399
R333 dvdd.t113 dvdd.n60 1.1255
R334 dvdd.t56 dvdd.t51 1.10636
R335 dvdd.n49 dvdd.n14 1.10263
R336 dvdd.n14 dvdd.n47 0.396973
R337 dvdd.n45 dvdd.n46 1.10263
R338 dvdd.t7 dvdd.t4 1.09475
R339 dvdd.t150 dvdd.n46 1.0943
R340 dvdd.t88 dvdd.t89 1.09202
R341 dvdd.t4 dvdd.t1 1.09025
R342 dvdd.n81 dvdd.t213 1.08575
R343 dvdd.n49 dvdd.n4 1.06126
R344 dvdd.n3 dvdd.n45 1.06126
R345 dvdd.n69 dvdd.t219 1.05257
R346 dvdd.t154 dvdd.t70 1.25195
R347 dvdd.n10 dvdd.n69 0.993915
R348 dvdd.t148 dvdd.n114 0.962214
R349 dvdd.t219 dvdd.t14 0.940235
R350 dvdd.n43 dvdd.t107 0.78244
R351 dvdd.n53 dvdd.n58 0.154053
R352 dvdd.t48 dvdd.t56 0.731451
R353 dvdd.n58 dvdd.n57 0.42624
R354 dvdd.n73 dvdd.n62 0.7005
R355 dvdd.n70 dvdd.n62 0.7005
R356 dvdd.t14 dvdd.n5 0.670094
R357 dvdd.n119 dvdd.t70 0.665394
R358 dvdd.n115 dvdd.n47 1.70707
R359 dvdd.n7 dvdd.n8 1.6036
R360 dvdd.t295 dvdd.n12 1.54079
R361 dvdd.n65 dvdd.n0 1.51543
R362 dvdd.n11 dvdd.t70 1.37145
R363 dvdd.n102 dvdd.t105 1.33893
R364 dvdd.n100 dvdd.t283 1.33893
R365 dvdd.n98 dvdd.t281 1.33764
R366 dvdd.t243 dvdd.n12 1.33636
R367 dvdd.t244 dvdd.n96 1.3325
R368 dvdd.n116 dvdd.n115 0.660923
R369 dvdd.n116 dvdd.n56 0.660923
R370 dvdd.n103 dvdd.n56 0.660923
R371 dvdd.n104 dvdd.n103 0.660923
R372 dvdd.n104 dvdd.n94 0.660923
R373 dvdd.n122 dvdd.t14 0.636382
R374 dvdd.n43 dvdd.n84 0.6305
R375 dvdd.n90 dvdd.t210 0.6305
R376 dvdd.n20 dvdd.n0 0.614299
R377 dvdd.t89 dvdd.t70 0.580561
R378 dvdd.n122 dvdd.t70 0.544201
R379 dvdd.n0 dvdd.t42 0.532342
R380 dvdd.n32 dvdd.n43 0.522486
R381 dvdd.n1 dvdd.n28 0.514942
R382 dvdd.t158 dvdd.n57 0.490031
R383 dvdd.n2 dvdd.t70 0.00140562
R384 dvdd.n25 dvdd.n8 0.457212
R385 dvdd.t160 dvdd.t163 0.451843
R386 dvdd.n91 dvdd.n85 0.4505
R387 dvdd.t107 dvdd.n85 0.4505
R388 dvdd.n91 dvdd.n86 0.4505
R389 dvdd.n86 dvdd.n32 0.4505
R390 dvdd.t161 dvdd.t158 0.435217
R391 dvdd.n87 dvdd.n34 0.904913
R392 dvdd.n15 dvdd.n27 0.604589
R393 dvdd.n14 dvdd.n26 0.604571
R394 dvdd.t70 dvdd.n1 0.512205
R395 dvdd.n25 dvdd.n76 0.392066
R396 dvdd.n92 dvdd.n83 0.381119
R397 dvdd.n31 dvdd.n30 0.375692
R398 dvdd.n107 dvdd.t294 0.373357
R399 dvdd.n34 dvdd.t299 0.135583
R400 dvdd.t42 dvdd.n5 0.368222
R401 dvdd.n105 dvdd.t150 0.361768
R402 dvdd.n109 dvdd.n45 0.361768
R403 dvdd.n77 dvdd.n8 0.357968
R404 dvdd.n106 dvdd.n46 0.35543
R405 dvdd.n49 dvdd.n48 0.35543
R406 dvdd.n110 dvdd.n3 0.352894
R407 dvdd.n79 dvdd.n78 0.3505
R408 dvdd.t56 dvdd.n5 0.346654
R409 dvdd.n54 dvdd.n16 1.13734
R410 dvdd.t14 dvdd.n6 1.10593
R411 dvdd.n34 dvdd.t210 0.11052
R412 dvdd.n29 dvdd.n51 0.33464
R413 dvdd.n23 dvdd.n22 0.3155
R414 dvdd.n66 dvdd.n18 0.3155
R415 dvdd.n89 dvdd.n40 0.291959
R416 dvdd.n37 dvdd.n36 0.286864
R417 dvdd.n70 dvdd.n67 0.280074
R418 dvdd.t299 dvdd.t107 0.275584
R419 dvdd.t210 dvdd.n32 0.271837
R420 dvdd.n51 dvdd.n59 0.265206
R421 dvdd.n121 dvdd.n38 0.263
R422 dvdd.n46 dvdd.n13 0.253356
R423 dvdd.t32 dvdd.t113 0.253054
R424 dvdd.t114 dvdd.t87 0.251115
R425 dvdd.n99 dvdd.n49 0.249606
R426 dvdd.n45 dvdd.n44 0.249606
R427 dvdd.n101 dvdd.n3 0.249606
R428 dvdd.n95 dvdd.t150 0.249606
R429 dvdd.t81 dvdd.t137 0.24875
R430 dvdd.t219 dvdd.n70 0.246245
R431 dvdd.n72 dvdd.n71 0.242808
R432 dvdd.n25 dvdd.n24 0.242808
R433 dvdd.n77 dvdd.n17 1.05192
R434 dvss.n77 dvss.n45 344182
R435 dvss.n72 dvss.n63 89135.9
R436 dvss.n68 dvss.n63 77858.1
R437 dvss.t24 dvss.n45 58601.1
R438 dvss.n26 dvss.n77 45707.2
R439 dvss.n77 dvss.n76 21441.1
R440 dvss.t1 dvss.n68 9771.24
R441 dvss.n72 dvss.t410 5273.95
R442 dvss.t410 dvss.t1 4573.35
R443 dvss.t1 dvss.t3 3469.5
R444 dvss.n67 dvss.t24 62.9437
R445 dvss.t24 dvss.t382 2526.28
R446 dvss.t84 dvss.t24 1072.39
R447 dvss.t125 dvss.t84 861.351
R448 dvss.n36 dvss.n21 4.99213
R449 dvss.n57 dvss.n62 0.0178743
R450 dvss.t0 dvss.t288 2.12235
R451 dvss.n74 dvss.n57 3.42592
R452 dvss.n73 dvss.t288 3.43875
R453 dvss.t383 dvss.t382 722.222
R454 dvss.n44 dvss.n59 678.558
R455 dvss.t142 dvss.n34 243.542
R456 dvss.n25 dvss.n80 0.346892
R457 dvss.n18 dvss.t31 273.034
R458 dvss.t408 dvss.t31 2.41986
R459 dvss.t323 dvss.t322 458.589
R460 dvss.n58 dvss.n34 0.894122
R461 dvss.n58 dvss.t323 5.14845
R462 dvss.n60 dvss.n42 356.243
R463 dvss.n45 dvss.n40 349.329
R464 dvss.n4 dvss.n5 0.598387
R465 dvss.t68 dvss.t72 291.433
R466 dvss.t72 dvss.t69 291.433
R467 dvss.t69 dvss.t73 291.433
R468 dvss.t74 dvss.t70 291.433
R469 dvss.t71 dvss.t74 291.433
R470 dvss.t75 dvss.t71 291.433
R471 dvss.t322 dvss.t125 287.118
R472 dvss.n27 dvss.n9 0.539965
R473 dvss.t249 dvss.t17 274.356
R474 dvss.t145 dvss.n39 259.443
R475 dvss.t145 dvss.n41 259.267
R476 dvss.n11 dvss.n10 0.556224
R477 dvss.t177 dvss.t175 234.647
R478 dvss.t198 dvss.t177 234.647
R479 dvss.t200 dvss.t181 234.647
R480 dvss.t202 dvss.t201 234.647
R481 dvss.t191 dvss.t202 234.647
R482 dvss.t205 dvss.t203 234.647
R483 dvss.t207 dvss.t206 234.647
R484 dvss.t193 dvss.t208 234.647
R485 dvss.t209 dvss.t193 234.647
R486 dvss.t211 dvss.t210 234.647
R487 dvss.t213 dvss.t212 234.647
R488 dvss.t214 dvss.t194 234.647
R489 dvss.t215 dvss.t214 234.647
R490 dvss.t179 dvss.t216 234.647
R491 dvss.t218 dvss.t217 234.647
R492 dvss.t393 dvss.t173 231.46
R493 dvss.t61 dvss.t24 227.111
R494 dvss.n74 dvss.n67 226.282
R495 dvss.t402 dvss.t213 224.029
R496 dvss.t330 dvss.t36 222.966
R497 dvss.n40 dvss.t68 219.226
R498 dvss.n78 dvss.n1 216.558
R499 dvss.n47 dvss.n1 215.171
R500 dvss.t203 dvss.t397 211.287
R501 dvss.n10 dvss.t75 194.506
R502 dvss.t210 dvss.t400 184.744
R503 dvss.t24 dvss.t324 177.379
R504 dvss.t269 dvss.t41 171.577
R505 dvss.t396 dvss.t200 170.941
R506 dvss.t280 dvss.t278 169.171
R507 dvss.t282 dvss.t281 169.171
R508 dvss.t283 dvss.t284 169.171
R509 dvss.t285 dvss.t286 169.171
R510 dvss.t162 dvss.t179 163.51
R511 dvss.t216 dvss.t403 158.201
R512 dvss.n33 dvss.t262 155.828
R513 dvss.t286 dvss.n26 155.547
R514 dvss.t243 dvss.t20 155
R515 dvss.t70 dvss.n22 150.922
R516 dvss.t181 dvss.t395 150.768
R517 dvss.t278 dvss.n27 149.302
R518 dvss.n4 dvss.t173 141.213
R519 dvss.t401 dvss.t211 136.965
R520 dvss.n22 dvss.n39 136.898
R521 dvss.t58 dvss.t24 135.935
R522 dvss.n22 dvss.n41 135.31
R523 dvss.t145 dvss.t73 134.007
R524 dvss.t263 dvss.t309 132.619
R525 dvss.t251 dvss.t59 132.619
R526 dvss.t258 dvss.t256 132.619
R527 dvss.t256 dvss.t332 132.619
R528 dvss.t261 dvss.t260 132.619
R529 dvss.t311 dvss.t310 132.619
R530 dvss.t21 dvss.t285 128.298
R531 dvss.t46 dvss.t307 127.647
R532 dvss.n72 dvss.t383 127.058
R533 dvss.t206 dvss.t398 124.225
R534 dvss.t66 dvss.t280 122.621
R535 dvss.n64 dvss.t269 121.016
R536 dvss.n44 dvss.n42 120.871
R537 dvss.t20 dvss.t324 120.186
R538 dvss.t322 dvss.n72 113.683
R539 dvss.t24 dvss.t243 111.07
R540 dvss.t398 dvss.t205 110.421
R541 dvss.t329 dvss.n12 8.51045
R542 dvss.t41 dvss.t311 103.609
R543 dvss.t264 dvss.t23 101.951
R544 dvss.t245 dvss.t312 98.0377
R545 dvss.t260 dvss.t62 97.8072
R546 dvss.t212 dvss.t401 97.681
R547 dvss.n44 dvss.t218 97.681
R548 dvss.n69 dvss.t28 96.6947
R549 dvss.t172 dvss.n4 58.6606
R550 dvss.n79 dvss.n27 92.3007
R551 dvss.n59 dvss.t207 87.0636
R552 dvss.n6 dvss.t282 86.8564
R553 dvss.t3 dvss.n71 83.9364
R554 dvss.t395 dvss.t198 83.8783
R555 dvss.t59 dvss.t30 82.0587
R556 dvss.t271 dvss.n64 81.2298
R557 dvss.n1 dvss.t283 81.1795
R558 dvss.t31 dvss.t38 77.7583
R559 dvss.n60 dvss.t399 77.5079
R560 dvss.t403 dvss.t215 76.4461
R561 dvss.t24 dvss.n63 75.505
R562 dvss.t24 dvss.n12 61.5452
R563 dvss.n14 dvss.t323 0.451781
R564 dvss.t309 dvss.t46 74.5988
R565 dvss.n71 dvss.t392 74.5356
R566 dvss.n6 dvss.n47 74.1215
R567 dvss.n78 dvss.n6 73.9521
R568 dvss.t259 dvss.t326 71.2833
R569 dvss.t217 dvss.t162 71.1374
R570 dvss.n69 dvss.t245 70.5067
R571 dvss.t67 dvss.t392 70.5067
R572 dvss.t298 dvss.t48 70.2603
R573 dvss.n7 dvss.n0 1.42564
R574 dvss.n70 dvss.n7 70.0005
R575 dvss.t339 dvss.t341 67.7609
R576 dvss.t26 dvss.t356 66.6501
R577 dvss.t16 dvss.t53 64.9838
R578 dvss.t24 dvss.t330 64.6524
R579 dvss.t201 dvss.t396 63.7052
R580 dvss.n79 dvss.n44 61.5817
R581 dvss.t310 dvss.t259 61.3369
R582 dvss.n27 dvss.n78 57.684
R583 dvss.n26 dvss.n47 57.5755
R584 dvss.t313 dvss.t321 55.8195
R585 dvss.t246 dvss.t55 55.8195
R586 dvss.n70 dvss.n8 55.8061
R587 dvss.n8 dvss.t24 0.725768
R588 dvss.t28 dvss.t327 55.734
R589 dvss.t277 dvss.t57 54.7087
R590 dvss.t327 dvss.n12 143.072
R591 dvss.n73 dvss.t50 54.1533
R592 dvss.t56 dvss.t336 53.0425
R593 dvss.t299 dvss.t353 52.7648
R594 dvss.t36 dvss.t261 52.2193
R595 dvss.n64 dvss.t24 25.77
R596 dvss.t24 dvss.n33 25.7686
R597 dvss.t30 dvss.t61 50.5616
R598 dvss.t400 dvss.t209 49.9025
R599 dvss.t307 dvss.t24 48.075
R600 dvss.t281 dvss.t66 46.5507
R601 dvss.n76 dvss.t339 45.2667
R602 dvss.t5 dvss.t7 44.4336
R603 dvss.t248 dvss.t13 44.4336
R604 dvss.t344 dvss.t294 44.4336
R605 dvss.t335 dvss.t275 44.4336
R606 dvss.n80 dvss.n42 43.2793
R607 dvss.t33 dvss.t254 43.045
R608 dvss.t380 dvss.t313 41.9342
R609 dvss.n74 dvss.t264 41.444
R610 dvss.t141 dvss.t296 41.3788
R611 dvss.t284 dvss.t21 40.8739
R612 dvss.t22 dvss.t297 40.8234
R613 dvss.t268 dvss.t18 40.268
R614 dvss.t266 dvss.t49 40.268
R615 dvss.t11 dvss.t43 39.1571
R616 dvss.t54 dvss.t11 38.6017
R617 dvss.t262 dvss.t251 38.1285
R618 dvss.t295 dvss.t76 37.4909
R619 dvss.t57 dvss.t342 37.4909
R620 dvss.t320 dvss.t412 37.2132
R621 dvss.t208 dvss.t399 37.1616
R622 dvss.t244 dvss.t67 36.9323
R623 dvss.t354 dvss.t301 35.8246
R624 dvss.t142 dvss.t407 35.2692
R625 dvss.t62 dvss.t271 34.813
R626 dvss.t338 dvss.t272 34.7138
R627 dvss.t119 dvss.t292 32.4922
R628 dvss.t180 dvss.n4 0.79885
R629 dvss.t23 dvss.t263 30.6687
R630 dvss.t359 dvss.t295 29.1597
R631 dvss.t287 dvss.n20 28.3266
R632 dvss.t49 dvss.t268 27.4935
R633 dvss.t35 dvss.t344 27.4935
R634 dvss.t316 dvss.t293 27.4935
R635 dvss.t315 dvss.t380 25.8272
R636 dvss.t302 dvss.t317 25.2718
R637 dvss.n76 dvss.t288 25.0749
R638 dvss.t24 dvss.t326 24.8666
R639 dvss.t252 dvss.t33 24.7164
R640 dvss.n36 dvss.t378 23.6056
R641 dvss.t7 dvss.t304 23.6056
R642 dvss.t397 dvss.t191 23.3589
R643 dvss.t113 dvss.t34 23.3279
R644 dvss.t254 dvss.t32 23.0501
R645 dvss.t42 dvss.t15 23.0501
R646 dvss.t29 dvss.t277 23.0501
R647 dvss.t304 dvss.t0 22.4947
R648 dvss.t292 dvss.t255 20.2731
R649 dvss.t39 dvss.t333 20.2731
R650 dvss.t318 dvss.t300 19.1623
R651 dvss.t353 dvss.t37 19.1623
R652 dvss.t43 dvss.t4 18.8845
R653 dvss.t275 dvss.t106 18.6068
R654 dvss.n40 dvss.n39 18.0764
R655 dvss.n10 dvss.n41 17.8992
R656 dvss.t15 dvss.t320 17.496
R657 dvss.t378 dvss.n75 16.1075
R658 dvss.t364 dvss.t319 16.1075
R659 dvss.n73 dvss.t289 16.1075
R660 dvss.t374 dvss.t252 15.2744
R661 dvss.t317 dvss.t338 15.2744
R662 dvss.t412 dvss.t63 12.775
R663 dvss.t48 dvss.t12 12.4973
R664 dvss.t370 dvss.t266 11.9419
R665 dvss.t55 dvss.t248 11.9419
R666 dvss.t290 dvss.t119 11.9419
R667 dvss.t47 dvss.t335 11.9419
R668 dvss.t32 dvss.t303 11.6642
R669 dvss.t368 dvss.t40 11.1088
R670 dvss.t194 dvss.t402 10.6179
R671 dvss.t341 dvss.n17 10.2756
R672 dvss.t8 dvss.t370 9.72023
R673 dvss.t272 dvss.t290 9.72023
R674 dvss.n72 dvss.t315 9.44252
R675 dvss.t350 dvss.t359 9.44252
R676 dvss.t312 dvss.t244 9.40133
R677 dvss.t351 dvss.t349 9.16482
R678 dvss.t319 dvss.t19 8.88711
R679 dvss.t366 dvss.t246 8.6094
R680 dvss.t300 dvss.t354 8.6094
R681 dvss.t40 dvss.t42 8.3317
R682 dvss.n33 dvss.t249 8.2892
R683 dvss.t333 dvss.t80 8.05399
R684 dvss.t163 dvss.n19 2.35691
R685 dvss.n15 dvss.t163 0.273534
R686 dvss.n15 dvss.t164 3.78273
R687 dvss.t166 dvss.t167 3.81637
R688 dvss.t169 dvss.t166 7.8365
R689 dvss.t138 dvss.n53 7.57332
R690 dvss.t132 dvss.n55 7.57332
R691 dvss.t126 dvss.n38 7.57332
R692 dvss.n28 dvss.t123 7.57332
R693 dvss.n31 dvss.t117 7.57332
R694 dvss.n48 dvss.t110 7.57332
R695 dvss.n49 dvss.t104 7.57332
R696 dvss.t45 dvss.t298 7.49858
R697 dvss.t407 dvss.t289 7.49858
R698 dvss.n57 dvss.t0 7.1459
R699 dvss.t357 dvss.t316 7.22087
R700 dvss.t135 dvss.n53 6.87903
R701 dvss.t129 dvss.n55 6.87903
R702 dvss.t85 dvss.n38 6.87903
R703 dvss.n28 dvss.t120 6.87903
R704 dvss.n31 dvss.t114 6.87903
R705 dvss.n48 dvss.t107 6.87903
R706 dvss.n49 dvss.t81 6.87903
R707 dvss.t19 dvss.t45 6.66546
R708 dvss.n54 dvss.t139 6.5794
R709 dvss.n52 dvss.t133 6.5794
R710 dvss.n56 dvss.t127 6.5794
R711 dvss.t124 dvss.n30 6.5794
R712 dvss.t118 dvss.n29 6.5794
R713 dvss.t111 dvss.n51 6.5794
R714 dvss.t105 dvss.n50 6.5794
R715 dvss.t37 dvss.t318 6.11004
R716 dvss.n54 dvss.t136 5.88512
R717 dvss.n52 dvss.t130 5.88512
R718 dvss.n56 dvss.t86 5.88512
R719 dvss.t121 dvss.n30 5.88512
R720 dvss.t115 dvss.n29 5.88512
R721 dvss.t108 dvss.n51 5.88512
R722 dvss.t82 dvss.n50 5.88512
R723 dvss.t9 dvss.t54 5.83234
R724 dvss.t349 dvss.t299 5.83234
R725 dvss.t294 dvss.t350 5.83234
R726 dvss.n17 dvss.n20 5.83234
R727 dvss.n66 dvss.n60 5.51095
R728 dvss.t265 dvss.n67 5.40971
R729 dvss.n75 dvss.t6 5.35271
R730 dvss.t297 dvss.t364 5.27692
R731 dvss.t355 dvss.t51 5.27692
R732 dvss.n5 dvss.n60 5.1891
R733 dvss.n75 dvss.n18 4.99922
R734 dvss.t303 dvss.t376 4.99922
R735 dvss.t27 dvss.t31 4.99922
R736 dvss.n65 dvss.t170 4.80337
R737 dvss.n35 dvss.n19 1.00397
R738 dvss.t376 dvss.t5 4.72151
R739 dvss.t342 dvss.t357 4.72151
R740 dvss.n58 dvss.t140 4.55777
R741 dvss.t306 dvss.n37 0.759555
R742 dvss.t296 dvss.t47 4.1661
R743 dvss.t408 dvss.t409 4.10458
R744 dvss.t321 dvss.n18 3.88839
R745 dvss.t53 dvss.t22 3.61069
R746 dvss.n59 dvss.n4 3.06956
R747 dvss.t161 dvss.n19 1.63738
R748 dvss.n65 dvss.t169 3.3365
R749 dvss.t255 dvss.t26 3.33298
R750 dvss.t175 dvss.t393 3.18573
R751 dvss.t24 dvss.t180 3.14769
R752 dvss.t301 dvss.t27 3.05527
R753 dvss.t0 dvss.n61 2.83382
R754 dvss.n3 dvss.n6 0.602727
R755 dvss.t18 dvss.t372 2.77757
R756 dvss.t51 dvss.t16 2.77757
R757 dvss.t106 dvss.t29 2.77757
R758 dvss.t34 dvss.t302 2.49986
R759 dvss.t306 dvss.t31 2.43462
R760 dvss.t305 dvss.t31 2.2639
R761 dvss.n46 dvss.t409 0.00595284
R762 dvss.t63 dvss.n34 1.32468
R763 dvss.t80 dvss.t141 2.22215
R764 dvss.t265 dvss.n32 3.82886
R765 dvss.n35 dvss.n59 3.26495
R766 dvss.n60 dvss.t180 2.20278
R767 dvss.t13 dvss.t368 1.94445
R768 dvss.t356 dvss.t351 1.94445
R769 dvss.n2 dvss.n1 0.494528
R770 dvss.n43 dvss.n35 1.78241
R771 dvss.n43 dvss.n66 1.77712
R772 dvss.t180 dvss.t279 1.70201
R773 dvss.t76 dvss.t56 1.66674
R774 dvss.t50 dvss.t39 1.66674
R775 dvss.t142 dvss.t287 1.66674
R776 dvss.t332 dvss.t58 1.65824
R777 dvss.n9 dvss.n1 1.60509
R778 dvss.t142 dvss.n23 1.1021
R779 dvss.t145 dvss.n13 0.451261
R780 dvss.n36 dvss.t24 1.48388
R781 dvss dvss.t63 1.46669
R782 dvss.n37 dvss.t305 0.876862
R783 dvss.t372 dvss.t9 1.38903
R784 dvss.t336 dvss.t113 1.38903
R785 dvss.n61 dvss.t25 1.3505
R786 dvss.t2 dvss.t242 1.3445
R787 dvss.t242 dvss.t257 1.3445
R788 dvss.t257 dvss.t60 1.3445
R789 dvss.t14 dvss.t291 1.3445
R790 dvss.t291 dvss.t276 1.3445
R791 dvss.t139 dvss.t138 1.31588
R792 dvss.t136 dvss.t135 1.31588
R793 dvss.t133 dvss.t132 1.31588
R794 dvss.t130 dvss.t129 1.31588
R795 dvss.t127 dvss.t126 1.31588
R796 dvss.t86 dvss.t85 1.31588
R797 dvss.t123 dvss.t124 1.31588
R798 dvss.t120 dvss.t121 1.31588
R799 dvss.t117 dvss.t118 1.31588
R800 dvss.t114 dvss.t115 1.31588
R801 dvss.t110 dvss.t111 1.31588
R802 dvss.t107 dvss.t108 1.31588
R803 dvss.t104 dvss.t105 1.31588
R804 dvss.t81 dvss.t82 1.31588
R805 dvss.n7 dvss.n68 1.3005
R806 dvss.t25 dvss.t347 1.2605
R807 dvss.t394 dvss.t195 1.25345
R808 dvss.n17 dvss.n46 1.19755
R809 dvss.t171 dvss.t196 1.15313
R810 dvss.t195 dvss.t171 1.15313
R811 dvss.n3 dvss.n1 0.291773
R812 dvss.n32 dvss.n62 0.115041
R813 dvss.t63 dvss.t83 1.12102
R814 dvss.t38 dvss.t355 1.11133
R815 dvss.t10 dvss.t14 1.09625
R816 dvss.t6 dvss.t10 1.09475
R817 dvss.t6 dvss.t2 1.09025
R818 dvss.t63 dvss.t112 1.08183
R819 dvss.n32 dvss.t24 0.212512
R820 dvss.t180 dvss.t204 1.01562
R821 dvss.n14 dvss.t24 1.00466
R822 dvss.t204 dvss.t192 1.00125
R823 dvss.t165 dvss.t166 0.425509
R824 dvss.n25 dvss.t180 0.888561
R825 dvss.t276 dvss.t288 0.8795
R826 dvss.t12 dvss.t366 0.83362
R827 dvss.t293 dvss.t35 0.83362
R828 dvss.t17 dvss.t258 0.82937
R829 dvss.n8 dvss.n69 0.743357
R830 dvss.t196 dvss.t394 0.668454
R831 dvss.t394 dvss.n5 0.660034
R832 dvss.n0 dvss.n71 1.26717
R833 dvss.n71 dvss.n70 0.6505
R834 dvss.n70 dvss.t273 0.6505
R835 dvss.t128 dvss.n54 0.615745
R836 dvss.t79 dvss.n49 0.615745
R837 dvss.t24 dvss.n0 0.0139169
R838 dvss.t128 dvss.n53 0.514786
R839 dvss.t128 dvss.n52 0.514786
R840 dvss.t128 dvss.n55 0.514786
R841 dvss.t128 dvss.n56 0.514786
R842 dvss.t83 dvss.n38 0.514786
R843 dvss.t112 dvss.n30 0.514786
R844 dvss.t112 dvss.n28 0.514786
R845 dvss.t112 dvss.n29 0.514786
R846 dvss.t112 dvss.n31 0.514786
R847 dvss.t79 dvss.n51 0.514786
R848 dvss.t79 dvss.n48 0.514786
R849 dvss.t79 dvss.n50 0.514786
R850 dvss.n21 dvss.n16 0.491664
R851 dvss.n27 dvss.n24 0.495921
R852 dvss.t347 dvss.t24 0.4505
R853 dvss.n66 dvss.n65 0.39425
R854 dvss.n58 dvss.t8 0.91957
R855 dvss.t306 dvss.n36 0.49084
R856 dvss.t83 dvss.t128 0.486699
R857 dvss.n36 dvss.t0 0.409572
R858 dvss.n62 dvss.n61 0.394734
R859 dvss.t60 dvss.t265 0.36575
R860 dvss.n80 dvss.n79 0.347167
R861 dvss.n25 dvss.n24 0.00155712
R862 dvss.t63 dvss.n23 0.0832234
R863 dvss.t4 dvss.t374 18.8845
R864 dvss.n46 dvss.t31 2.50533
R865 dvss.n40 dvss.n13 0.608197
R866 dvss.t192 dvss.t171 1.25144
R867 dvss.t112 dvss.t79 0.734448
R868 dvss.n26 dvss.n2 0.324433
R869 dvss.n16 dvss.n20 0.547868
R870 dvss.n43 dvss.n9 0.0040483
R871 dvss.t63 dvss.t24 0.456736
R872 dvss.t165 dvss.t163 0.188125
R873 dvss.n17 dvss.t408 1.2966
R874 dvss.t140 dvss.t142 1.13223
R875 dvss.t288 dvss.n16 0.789892
R876 dvss.t145 dvss.n4 0.614324
R877 dvss.n15 dvss.t166 0.273534
R878 dvss.n18 dvss.n37 0.546457
R879 dvss.t166 dvss.t170 0.524974
R880 dvss.n44 dvss.n43 0.479839
R881 dvss.t408 dvss.n21 0.469696
R882 dvss.n23 dvss.n14 4.87876
R883 dvss.n13 dvss.n22 1.44105
R884 dvss.n22 dvss.n11 1.96879
R885 dvss.n3 dvss.n24 0.721405
R886 dvss.n11 dvss.n4 1.17857
R887 dvss.n2 dvss.n6 1.29993
R888 dvss.t273 dvss.t24 1.04291
R889 gf180mcu_ocd_ip__classab_buffer_0.se_folded_cascode_np_ab_0.pfet_03v3_XWLNX2_0.D.n74 gf180mcu_ocd_ip__classab_buffer_0.se_folded_cascode_np_ab_0.pfet_03v3_XWLNX2_0.D 7.81818
R890 gf180mcu_ocd_ip__classab_buffer_0.se_folded_cascode_np_ab_0.pfet_03v3_XWLNX2_0.D.n79 gf180mcu_ocd_ip__classab_buffer_0.se_folded_cascode_np_ab_0.pfet_03v3_XWLNX2_0.D 7.76689
R891 gf180mcu_ocd_ip__classab_buffer_0.se_folded_cascode_np_ab_0.pfet_03v3_XWLNX2_0.D.n81 gf180mcu_ocd_ip__classab_buffer_0.se_folded_cascode_np_ab_0.pfet_03v3_XWLNX2_0.D 7.15989
R892 gf180mcu_ocd_ip__classab_buffer_0.se_folded_cascode_np_ab_0.pfet_03v3_XWLNX2_0.D.n83 gf180mcu_ocd_ip__classab_buffer_0.se_folded_cascode_np_ab_0.pfet_03v3_XWLNX2_0.D 7.15877
R893 gf180mcu_ocd_ip__classab_buffer_0.se_folded_cascode_np_ab_0.pfet_03v3_XWLNX2_0.D.n22 gf180mcu_ocd_ip__classab_buffer_0.se_folded_cascode_np_ab_0.pfet_03v3_XWLNX2_0.D 6.87961
R894 gf180mcu_ocd_ip__classab_buffer_0.se_folded_cascode_np_ab_0.pfet_03v3_XWLNX2_0.D.n21 gf180mcu_ocd_ip__classab_buffer_0.se_folded_cascode_np_ab_0.pfet_03v3_XWLNX2_0.D 6.87961
R895 gf180mcu_ocd_ip__classab_buffer_0.se_folded_cascode_np_ab_0.pfet_03v3_XWLNX2_0.D.n20 gf180mcu_ocd_ip__classab_buffer_0.se_folded_cascode_np_ab_0.pfet_03v3_XWLNX2_0.D 6.87961
R896 gf180mcu_ocd_ip__classab_buffer_0.se_folded_cascode_np_ab_0.pfet_03v3_XWLNX2_0.D.n0 gf180mcu_ocd_ip__classab_buffer_0.se_folded_cascode_np_ab_0.pfet_03v3_XWLNX2_0.D 6.87961
R897 gf180mcu_ocd_ip__classab_buffer_0.se_folded_cascode_np_ab_0.pfet_03v3_XWLNX2_0.D.n27 gf180mcu_ocd_ip__classab_buffer_0.se_folded_cascode_np_ab_0.pfet_03v3_XWLNX2_0.D 6.85389
R898 gf180mcu_ocd_ip__classab_buffer_0.se_folded_cascode_np_ab_0.pfet_03v3_XWLNX2_0.D.n26 gf180mcu_ocd_ip__classab_buffer_0.se_folded_cascode_np_ab_0.pfet_03v3_XWLNX2_0.D 6.85389
R899 gf180mcu_ocd_ip__classab_buffer_0.se_folded_cascode_np_ab_0.pfet_03v3_XWLNX2_0.D.n23 gf180mcu_ocd_ip__classab_buffer_0.se_folded_cascode_np_ab_0.pfet_03v3_XWLNX2_0.D 6.85389
R900 gf180mcu_ocd_ip__classab_buffer_0.se_folded_cascode_np_ab_0.pfet_03v3_XWLNX2_0.D.n32 gf180mcu_ocd_ip__classab_buffer_0.se_folded_cascode_np_ab_0.pfet_03v3_XWLNX2_0.D 6.82818
R901 gf180mcu_ocd_ip__classab_buffer_0.se_folded_cascode_np_ab_0.pfet_03v3_XWLNX2_0.D.n30 gf180mcu_ocd_ip__classab_buffer_0.se_folded_cascode_np_ab_0.pfet_03v3_XWLNX2_0.D 6.82818
R902 gf180mcu_ocd_ip__classab_buffer_0.se_folded_cascode_np_ab_0.pfet_03v3_XWLNX2_0.D.n29 gf180mcu_ocd_ip__classab_buffer_0.se_folded_cascode_np_ab_0.pfet_03v3_XWLNX2_0.D 6.82818
R903 gf180mcu_ocd_ip__classab_buffer_0.se_folded_cascode_np_ab_0.pfet_03v3_XWLNX2_0.D.n2 gf180mcu_ocd_ip__classab_buffer_0.se_folded_cascode_np_ab_0.pfet_03v3_XWLNX2_0.D 6.82818
R904 gf180mcu_ocd_ip__classab_buffer_0.se_folded_cascode_np_ab_0.pfet_03v3_XWLNX2_0.D.n19 gf180mcu_ocd_ip__classab_buffer_0.se_folded_cascode_np_ab_0.pfet_03v3_XWLNX2_0.D 6.80261
R905 gf180mcu_ocd_ip__classab_buffer_0.se_folded_cascode_np_ab_0.pfet_03v3_XWLNX2_0.D.n17 gf180mcu_ocd_ip__classab_buffer_0.se_folded_cascode_np_ab_0.pfet_03v3_XWLNX2_0.D 6.80261
R906 gf180mcu_ocd_ip__classab_buffer_0.se_folded_cascode_np_ab_0.pfet_03v3_XWLNX2_0.D.n16 gf180mcu_ocd_ip__classab_buffer_0.se_folded_cascode_np_ab_0.pfet_03v3_XWLNX2_0.D 6.80261
R907 gf180mcu_ocd_ip__classab_buffer_0.se_folded_cascode_np_ab_0.pfet_03v3_XWLNX2_0.D.n53 gf180mcu_ocd_ip__classab_buffer_0.se_folded_cascode_np_ab_0.pfet_03v3_XWLNX2_0.D 6.33639
R908 gf180mcu_ocd_ip__classab_buffer_0.se_folded_cascode_np_ab_0.pfet_03v3_XWLNX2_0.D.n52 gf180mcu_ocd_ip__classab_buffer_0.se_folded_cascode_np_ab_0.pfet_03v3_XWLNX2_0.D 6.33639
R909 gf180mcu_ocd_ip__classab_buffer_0.se_folded_cascode_np_ab_0.pfet_03v3_XWLNX2_0.D.n51 gf180mcu_ocd_ip__classab_buffer_0.se_folded_cascode_np_ab_0.pfet_03v3_XWLNX2_0.D 6.33639
R910 gf180mcu_ocd_ip__classab_buffer_0.se_folded_cascode_np_ab_0.pfet_03v3_XWLNX2_0.D.n50 gf180mcu_ocd_ip__classab_buffer_0.se_folded_cascode_np_ab_0.pfet_03v3_XWLNX2_0.D 6.33639
R911 gf180mcu_ocd_ip__classab_buffer_0.se_folded_cascode_np_ab_0.pfet_03v3_XWLNX2_0.D.n48 gf180mcu_ocd_ip__classab_buffer_0.se_folded_cascode_np_ab_0.pfet_03v3_XWLNX2_0.D 6.33639
R912 gf180mcu_ocd_ip__classab_buffer_0.se_folded_cascode_np_ab_0.pfet_03v3_XWLNX2_0.D.n47 gf180mcu_ocd_ip__classab_buffer_0.se_folded_cascode_np_ab_0.pfet_03v3_XWLNX2_0.D 6.33639
R913 gf180mcu_ocd_ip__classab_buffer_0.se_folded_cascode_np_ab_0.pfet_03v3_XWLNX2_0.D.n46 gf180mcu_ocd_ip__classab_buffer_0.se_folded_cascode_np_ab_0.pfet_03v3_XWLNX2_0.D 6.33639
R914 gf180mcu_ocd_ip__classab_buffer_0.se_folded_cascode_np_ab_0.pfet_03v3_XWLNX2_0.D.n44 gf180mcu_ocd_ip__classab_buffer_0.se_folded_cascode_np_ab_0.pfet_03v3_XWLNX2_0.D 6.33639
R915 gf180mcu_ocd_ip__classab_buffer_0.se_folded_cascode_np_ab_0.pfet_03v3_XWLNX2_0.D.n43 gf180mcu_ocd_ip__classab_buffer_0.se_folded_cascode_np_ab_0.pfet_03v3_XWLNX2_0.D 6.33639
R916 gf180mcu_ocd_ip__classab_buffer_0.se_folded_cascode_np_ab_0.pfet_03v3_XWLNX2_0.D.n14 gf180mcu_ocd_ip__classab_buffer_0.se_folded_cascode_np_ab_0.pfet_03v3_XWLNX2_0.D 6.33639
R917 gf180mcu_ocd_ip__classab_buffer_0.se_folded_cascode_np_ab_0.pfet_03v3_XWLNX2_0.D.n57 gf180mcu_ocd_ip__classab_buffer_0.se_folded_cascode_np_ab_0.pfet_03v3_XWLNX2_0.D 6.33479
R918 gf180mcu_ocd_ip__classab_buffer_0.se_folded_cascode_np_ab_0.pfet_03v3_XWLNX2_0.D.n56 gf180mcu_ocd_ip__classab_buffer_0.se_folded_cascode_np_ab_0.pfet_03v3_XWLNX2_0.D 6.33479
R919 gf180mcu_ocd_ip__classab_buffer_0.se_folded_cascode_np_ab_0.pfet_03v3_XWLNX2_0.D.n54 gf180mcu_ocd_ip__classab_buffer_0.se_folded_cascode_np_ab_0.pfet_03v3_XWLNX2_0.D 6.33479
R920 gf180mcu_ocd_ip__classab_buffer_0.se_folded_cascode_np_ab_0.pfet_03v3_XWLNX2_0.D.n13 gf180mcu_ocd_ip__classab_buffer_0.se_folded_cascode_np_ab_0.pfet_03v3_XWLNX2_0.D 6.33479
R921 gf180mcu_ocd_ip__classab_buffer_0.se_folded_cascode_np_ab_0.pfet_03v3_XWLNX2_0.D.n39 gf180mcu_ocd_ip__classab_buffer_0.se_folded_cascode_np_ab_0.pfet_03v3_XWLNX2_0.D.n0 5.93629
R922 gf180mcu_ocd_ip__classab_buffer_0.se_folded_cascode_np_ab_0.pfet_03v3_XWLNX2_0.D gf180mcu_ocd_ip__classab_buffer_0.se_folded_cascode_np_ab_0.pfet_03v3_XWLNX2_0.D.n97 5.86266
R923 gf180mcu_ocd_ip__classab_buffer_0.se_folded_cascode_np_ab_0.pfet_03v3_XWLNX2_0.D gf180mcu_ocd_ip__classab_buffer_0.se_folded_cascode_np_ab_0.pfet_03v3_XWLNX2_0.D.t39 5.80436
R924 gf180mcu_ocd_ip__classab_buffer_0.se_folded_cascode_np_ab_0.pfet_03v3_XWLNX2_0.D gf180mcu_ocd_ip__classab_buffer_0.se_folded_cascode_np_ab_0.pfet_03v3_XWLNX2_0.D.t41 2.5815
R925 gf180mcu_ocd_ip__classab_buffer_0.se_folded_cascode_np_ab_0.pfet_03v3_XWLNX2_0.D gf180mcu_ocd_ip__classab_buffer_0.se_folded_cascode_np_ab_0.pfet_03v3_XWLNX2_0.D.t45 5.80436
R926 gf180mcu_ocd_ip__classab_buffer_0.se_folded_cascode_np_ab_0.pfet_03v3_XWLNX2_0.D.t40 gf180mcu_ocd_ip__classab_buffer_0.se_folded_cascode_np_ab_0.pfet_03v3_XWLNX2_0.D 5.80436
R927 gf180mcu_ocd_ip__classab_buffer_0.se_folded_cascode_np_ab_0.pfet_03v3_XWLNX2_0.D gf180mcu_ocd_ip__classab_buffer_0.se_folded_cascode_np_ab_0.pfet_03v3_XWLNX2_0.D.t42 2.5815
R928 gf180mcu_ocd_ip__classab_buffer_0.se_folded_cascode_np_ab_0.pfet_03v3_XWLNX2_0.D gf180mcu_ocd_ip__classab_buffer_0.se_folded_cascode_np_ab_0.pfet_03v3_XWLNX2_0.D.t44 2.5815
R929 gf180mcu_ocd_ip__classab_buffer_0.se_folded_cascode_np_ab_0.pfet_03v3_XWLNX2_0.D.n82 gf180mcu_ocd_ip__classab_buffer_0.se_folded_cascode_np_ab_0.pfet_03v3_XWLNX2_0.D.n13 5.75773
R930 gf180mcu_ocd_ip__classab_buffer_0.se_folded_cascode_np_ab_0.pfet_03v3_XWLNX2_0.D.n61 gf180mcu_ocd_ip__classab_buffer_0.se_folded_cascode_np_ab_0.pfet_03v3_XWLNX2_0.D.n60 5.40336
R931 gf180mcu_ocd_ip__classab_buffer_0.se_folded_cascode_np_ab_0.pfet_03v3_XWLNX2_0.D.n57 gf180mcu_ocd_ip__classab_buffer_0.se_folded_cascode_np_ab_0.pfet_03v3_XWLNX2_0.D.n4 5.40336
R932 gf180mcu_ocd_ip__classab_buffer_0.se_folded_cascode_np_ab_0.pfet_03v3_XWLNX2_0.D.n6 gf180mcu_ocd_ip__classab_buffer_0.se_folded_cascode_np_ab_0.pfet_03v3_XWLNX2_0.D.n55 5.40336
R933 gf180mcu_ocd_ip__classab_buffer_0.se_folded_cascode_np_ab_0.pfet_03v3_XWLNX2_0.D.n89 gf180mcu_ocd_ip__classab_buffer_0.se_folded_cascode_np_ab_0.pfet_03v3_XWLNX2_0.D.n56 5.40336
R934 gf180mcu_ocd_ip__classab_buffer_0.se_folded_cascode_np_ab_0.pfet_03v3_XWLNX2_0.D.n88 gf180mcu_ocd_ip__classab_buffer_0.se_folded_cascode_np_ab_0.pfet_03v3_XWLNX2_0.D.n87 5.40336
R935 gf180mcu_ocd_ip__classab_buffer_0.se_folded_cascode_np_ab_0.pfet_03v3_XWLNX2_0.D.n85 gf180mcu_ocd_ip__classab_buffer_0.se_folded_cascode_np_ab_0.pfet_03v3_XWLNX2_0.D.n54 5.40336
R936 gf180mcu_ocd_ip__classab_buffer_0.se_folded_cascode_np_ab_0.pfet_03v3_XWLNX2_0.D.n13 gf180mcu_ocd_ip__classab_buffer_0.se_folded_cascode_np_ab_0.pfet_03v3_XWLNX2_0.D.n84 5.40336
R937 gf180mcu_ocd_ip__classab_buffer_0.se_folded_cascode_np_ab_0.pfet_03v3_XWLNX2_0.D.n66 gf180mcu_ocd_ip__classab_buffer_0.se_folded_cascode_np_ab_0.pfet_03v3_XWLNX2_0.D.n40 5.24381
R938 gf180mcu_ocd_ip__classab_buffer_0.se_folded_cascode_np_ab_0.pfet_03v3_XWLNX2_0.D.n2 gf180mcu_ocd_ip__classab_buffer_0.se_folded_cascode_np_ab_0.pfet_03v3_XWLNX2_0.D.n39 5.2205
R939 gf180mcu_ocd_ip__classab_buffer_0.se_folded_cascode_np_ab_0.pfet_03v3_XWLNX2_0.D.n33 gf180mcu_ocd_ip__classab_buffer_0.se_folded_cascode_np_ab_0.pfet_03v3_XWLNX2_0.D.n66 5.21629
R940 gf180mcu_ocd_ip__classab_buffer_0.se_folded_cascode_np_ab_0.pfet_03v3_XWLNX2_0.D.n34 gf180mcu_ocd_ip__classab_buffer_0.se_folded_cascode_np_ab_0.pfet_03v3_XWLNX2_0.D.n22 5.21629
R941 gf180mcu_ocd_ip__classab_buffer_0.se_folded_cascode_np_ab_0.pfet_03v3_XWLNX2_0.D.n65 gf180mcu_ocd_ip__classab_buffer_0.se_folded_cascode_np_ab_0.pfet_03v3_XWLNX2_0.D.n36 5.21629
R942 gf180mcu_ocd_ip__classab_buffer_0.se_folded_cascode_np_ab_0.pfet_03v3_XWLNX2_0.D.n63 gf180mcu_ocd_ip__classab_buffer_0.se_folded_cascode_np_ab_0.pfet_03v3_XWLNX2_0.D.n24 5.21629
R943 gf180mcu_ocd_ip__classab_buffer_0.se_folded_cascode_np_ab_0.pfet_03v3_XWLNX2_0.D.n20 gf180mcu_ocd_ip__classab_buffer_0.se_folded_cascode_np_ab_0.pfet_03v3_XWLNX2_0.D.n28 5.21629
R944 gf180mcu_ocd_ip__classab_buffer_0.se_folded_cascode_np_ab_0.pfet_03v3_XWLNX2_0.D.n1 gf180mcu_ocd_ip__classab_buffer_0.se_folded_cascode_np_ab_0.pfet_03v3_XWLNX2_0.D.n0 5.21629
R945 gf180mcu_ocd_ip__classab_buffer_0.se_folded_cascode_np_ab_0.pfet_03v3_XWLNX2_0.D.n72 gf180mcu_ocd_ip__classab_buffer_0.se_folded_cascode_np_ab_0.pfet_03v3_XWLNX2_0.D.n21 5.21629
R946 gf180mcu_ocd_ip__classab_buffer_0.se_folded_cascode_np_ab_0.pfet_03v3_XWLNX2_0.D.t39 gf180mcu_ocd_ip__classab_buffer_0.se_folded_cascode_np_ab_0.pfet_03v3_XWLNX2_0.D 5.1615
R947 gf180mcu_ocd_ip__classab_buffer_0.se_folded_cascode_np_ab_0.pfet_03v3_XWLNX2_0.D gf180mcu_ocd_ip__classab_buffer_0.se_folded_cascode_np_ab_0.pfet_03v3_XWLNX2_0.D.t43 2.5815
R948 gf180mcu_ocd_ip__classab_buffer_0.se_folded_cascode_np_ab_0.pfet_03v3_XWLNX2_0.D.t45 gf180mcu_ocd_ip__classab_buffer_0.se_folded_cascode_np_ab_0.pfet_03v3_XWLNX2_0.D 5.1615
R949 gf180mcu_ocd_ip__classab_buffer_0.se_folded_cascode_np_ab_0.pfet_03v3_XWLNX2_0.D gf180mcu_ocd_ip__classab_buffer_0.se_folded_cascode_np_ab_0.pfet_03v3_XWLNX2_0.D.t38 2.5815
R950 gf180mcu_ocd_ip__classab_buffer_0.se_folded_cascode_np_ab_0.pfet_03v3_XWLNX2_0.D gf180mcu_ocd_ip__classab_buffer_0.se_folded_cascode_np_ab_0.pfet_03v3_XWLNX2_0.D.t40 5.1615
R951 gf180mcu_ocd_ip__classab_buffer_0.se_folded_cascode_np_ab_0.pfet_03v3_XWLNX2_0.D.n67 gf180mcu_ocd_ip__classab_buffer_0.se_folded_cascode_np_ab_0.pfet_03v3_XWLNX2_0.D.n40 4.90506
R952 gf180mcu_ocd_ip__classab_buffer_0.se_folded_cascode_np_ab_0.pfet_03v3_XWLNX2_0.D.n40 gf180mcu_ocd_ip__classab_buffer_0.se_folded_cascode_np_ab_0.pfet_03v3_XWLNX2_0.D.n95 4.90336
R953 gf180mcu_ocd_ip__classab_buffer_0.se_folded_cascode_np_ab_0.pfet_03v3_XWLNX2_0.D.n31 gf180mcu_ocd_ip__classab_buffer_0.se_folded_cascode_np_ab_0.pfet_03v3_XWLNX2_0.D.n40 4.90282
R954 gf180mcu_ocd_ip__classab_buffer_0.se_folded_cascode_np_ab_0.pfet_03v3_XWLNX2_0.D.n12 gf180mcu_ocd_ip__classab_buffer_0.se_folded_cascode_np_ab_0.pfet_03v3_XWLNX2_0.D.n14 4.8605
R955 gf180mcu_ocd_ip__classab_buffer_0.se_folded_cascode_np_ab_0.pfet_03v3_XWLNX2_0.D.n60 gf180mcu_ocd_ip__classab_buffer_0.se_folded_cascode_np_ab_0.pfet_03v3_XWLNX2_0.D.n41 4.50487
R956 gf180mcu_ocd_ip__classab_buffer_0.se_folded_cascode_np_ab_0.pfet_03v3_XWLNX2_0.D.n12 gf180mcu_ocd_ip__classab_buffer_0.se_folded_cascode_np_ab_0.pfet_03v3_XWLNX2_0.D.n81 4.5005
R957 gf180mcu_ocd_ip__classab_buffer_0.se_folded_cascode_np_ab_0.pfet_03v3_XWLNX2_0.D.n51 gf180mcu_ocd_ip__classab_buffer_0.se_folded_cascode_np_ab_0.pfet_03v3_XWLNX2_0.D.n11 4.5005
R958 gf180mcu_ocd_ip__classab_buffer_0.se_folded_cascode_np_ab_0.pfet_03v3_XWLNX2_0.D.n10 gf180mcu_ocd_ip__classab_buffer_0.se_folded_cascode_np_ab_0.pfet_03v3_XWLNX2_0.D.n77 4.5005
R959 gf180mcu_ocd_ip__classab_buffer_0.se_folded_cascode_np_ab_0.pfet_03v3_XWLNX2_0.D.n52 gf180mcu_ocd_ip__classab_buffer_0.se_folded_cascode_np_ab_0.pfet_03v3_XWLNX2_0.D.n9 4.5005
R960 gf180mcu_ocd_ip__classab_buffer_0.se_folded_cascode_np_ab_0.pfet_03v3_XWLNX2_0.D.n8 gf180mcu_ocd_ip__classab_buffer_0.se_folded_cascode_np_ab_0.pfet_03v3_XWLNX2_0.D.n64 4.5005
R961 gf180mcu_ocd_ip__classab_buffer_0.se_folded_cascode_np_ab_0.pfet_03v3_XWLNX2_0.D.n53 gf180mcu_ocd_ip__classab_buffer_0.se_folded_cascode_np_ab_0.pfet_03v3_XWLNX2_0.D.n7 4.5005
R962 gf180mcu_ocd_ip__classab_buffer_0.se_folded_cascode_np_ab_0.pfet_03v3_XWLNX2_0.D.n92 gf180mcu_ocd_ip__classab_buffer_0.se_folded_cascode_np_ab_0.pfet_03v3_XWLNX2_0.D.n5 4.5005
R963 gf180mcu_ocd_ip__classab_buffer_0.se_folded_cascode_np_ab_0.pfet_03v3_XWLNX2_0.D.n3 gf180mcu_ocd_ip__classab_buffer_0.se_folded_cascode_np_ab_0.pfet_03v3_XWLNX2_0.D.n93 4.5005
R964 gf180mcu_ocd_ip__classab_buffer_0.se_folded_cascode_np_ab_0.pfet_03v3_XWLNX2_0.D.n45 gf180mcu_ocd_ip__classab_buffer_0.se_folded_cascode_np_ab_0.pfet_03v3_XWLNX2_0.D.n3 4.5005
R965 gf180mcu_ocd_ip__classab_buffer_0.se_folded_cascode_np_ab_0.pfet_03v3_XWLNX2_0.D.n62 gf180mcu_ocd_ip__classab_buffer_0.se_folded_cascode_np_ab_0.pfet_03v3_XWLNX2_0.D.n61 4.5005
R966 gf180mcu_ocd_ip__classab_buffer_0.se_folded_cascode_np_ab_0.pfet_03v3_XWLNX2_0.D.n83 gf180mcu_ocd_ip__classab_buffer_0.se_folded_cascode_np_ab_0.pfet_03v3_XWLNX2_0.D.n82 4.5005
R967 gf180mcu_ocd_ip__classab_buffer_0.se_folded_cascode_np_ab_0.pfet_03v3_XWLNX2_0.D.n84 gf180mcu_ocd_ip__classab_buffer_0.se_folded_cascode_np_ab_0.pfet_03v3_XWLNX2_0.D.n47 4.5005
R968 gf180mcu_ocd_ip__classab_buffer_0.se_folded_cascode_np_ab_0.pfet_03v3_XWLNX2_0.D.n86 gf180mcu_ocd_ip__classab_buffer_0.se_folded_cascode_np_ab_0.pfet_03v3_XWLNX2_0.D.n85 4.5005
R969 gf180mcu_ocd_ip__classab_buffer_0.se_folded_cascode_np_ab_0.pfet_03v3_XWLNX2_0.D.n87 gf180mcu_ocd_ip__classab_buffer_0.se_folded_cascode_np_ab_0.pfet_03v3_XWLNX2_0.D.n48 4.5005
R970 gf180mcu_ocd_ip__classab_buffer_0.se_folded_cascode_np_ab_0.pfet_03v3_XWLNX2_0.D.n90 gf180mcu_ocd_ip__classab_buffer_0.se_folded_cascode_np_ab_0.pfet_03v3_XWLNX2_0.D.n89 4.5005
R971 gf180mcu_ocd_ip__classab_buffer_0.se_folded_cascode_np_ab_0.pfet_03v3_XWLNX2_0.D.n6 gf180mcu_ocd_ip__classab_buffer_0.se_folded_cascode_np_ab_0.pfet_03v3_XWLNX2_0.D.n50 4.5005
R972 gf180mcu_ocd_ip__classab_buffer_0.se_folded_cascode_np_ab_0.pfet_03v3_XWLNX2_0.D.n49 gf180mcu_ocd_ip__classab_buffer_0.se_folded_cascode_np_ab_0.pfet_03v3_XWLNX2_0.D.n4 4.5005
R973 gf180mcu_ocd_ip__classab_buffer_0.se_folded_cascode_np_ab_0.pfet_03v3_XWLNX2_0.D.n79 gf180mcu_ocd_ip__classab_buffer_0.se_folded_cascode_np_ab_0.pfet_03v3_XWLNX2_0.D.n38 4.5005
R974 gf180mcu_ocd_ip__classab_buffer_0.se_folded_cascode_np_ab_0.pfet_03v3_XWLNX2_0.D.n80 gf180mcu_ocd_ip__classab_buffer_0.se_folded_cascode_np_ab_0.pfet_03v3_XWLNX2_0.D.n16 4.5005
R975 gf180mcu_ocd_ip__classab_buffer_0.se_folded_cascode_np_ab_0.pfet_03v3_XWLNX2_0.D.n15 gf180mcu_ocd_ip__classab_buffer_0.se_folded_cascode_np_ab_0.pfet_03v3_XWLNX2_0.D.n78 4.5005
R976 gf180mcu_ocd_ip__classab_buffer_0.se_folded_cascode_np_ab_0.pfet_03v3_XWLNX2_0.D.n76 gf180mcu_ocd_ip__classab_buffer_0.se_folded_cascode_np_ab_0.pfet_03v3_XWLNX2_0.D.n17 4.5005
R977 gf180mcu_ocd_ip__classab_buffer_0.se_folded_cascode_np_ab_0.pfet_03v3_XWLNX2_0.D.n37 gf180mcu_ocd_ip__classab_buffer_0.se_folded_cascode_np_ab_0.pfet_03v3_XWLNX2_0.D.n71 4.5005
R978 gf180mcu_ocd_ip__classab_buffer_0.se_folded_cascode_np_ab_0.pfet_03v3_XWLNX2_0.D.n19 gf180mcu_ocd_ip__classab_buffer_0.se_folded_cascode_np_ab_0.pfet_03v3_XWLNX2_0.D.n70 4.5005
R979 gf180mcu_ocd_ip__classab_buffer_0.se_folded_cascode_np_ab_0.pfet_03v3_XWLNX2_0.D.n35 gf180mcu_ocd_ip__classab_buffer_0.se_folded_cascode_np_ab_0.pfet_03v3_XWLNX2_0.D.n18 4.5005
R980 gf180mcu_ocd_ip__classab_buffer_0.se_folded_cascode_np_ab_0.pfet_03v3_XWLNX2_0.D.n95 gf180mcu_ocd_ip__classab_buffer_0.se_folded_cascode_np_ab_0.pfet_03v3_XWLNX2_0.D.n94 4.5005
R981 gf180mcu_ocd_ip__classab_buffer_0.se_folded_cascode_np_ab_0.pfet_03v3_XWLNX2_0.D.n31 gf180mcu_ocd_ip__classab_buffer_0.se_folded_cascode_np_ab_0.pfet_03v3_XWLNX2_0.D.n33 4.5005
R982 gf180mcu_ocd_ip__classab_buffer_0.se_folded_cascode_np_ab_0.pfet_03v3_XWLNX2_0.D.n67 gf180mcu_ocd_ip__classab_buffer_0.se_folded_cascode_np_ab_0.pfet_03v3_XWLNX2_0.D.n33 4.5005
R983 gf180mcu_ocd_ip__classab_buffer_0.se_folded_cascode_np_ab_0.pfet_03v3_XWLNX2_0.D.n34 gf180mcu_ocd_ip__classab_buffer_0.se_folded_cascode_np_ab_0.pfet_03v3_XWLNX2_0.D.n68 4.5005
R984 gf180mcu_ocd_ip__classab_buffer_0.se_folded_cascode_np_ab_0.pfet_03v3_XWLNX2_0.D.n32 gf180mcu_ocd_ip__classab_buffer_0.se_folded_cascode_np_ab_0.pfet_03v3_XWLNX2_0.D.n35 4.5005
R985 gf180mcu_ocd_ip__classab_buffer_0.se_folded_cascode_np_ab_0.pfet_03v3_XWLNX2_0.D.n5 gf180mcu_ocd_ip__classab_buffer_0.se_folded_cascode_np_ab_0.pfet_03v3_XWLNX2_0.D.n46 4.5005
R986 gf180mcu_ocd_ip__classab_buffer_0.se_folded_cascode_np_ab_0.pfet_03v3_XWLNX2_0.D.n91 gf180mcu_ocd_ip__classab_buffer_0.se_folded_cascode_np_ab_0.pfet_03v3_XWLNX2_0.D.n7 4.5005
R987 gf180mcu_ocd_ip__classab_buffer_0.se_folded_cascode_np_ab_0.pfet_03v3_XWLNX2_0.D.n36 gf180mcu_ocd_ip__classab_buffer_0.se_folded_cascode_np_ab_0.pfet_03v3_XWLNX2_0.D.n69 4.5005
R988 gf180mcu_ocd_ip__classab_buffer_0.se_folded_cascode_np_ab_0.pfet_03v3_XWLNX2_0.D.n36 gf180mcu_ocd_ip__classab_buffer_0.se_folded_cascode_np_ab_0.pfet_03v3_XWLNX2_0.D.n27 4.5005
R989 gf180mcu_ocd_ip__classab_buffer_0.se_folded_cascode_np_ab_0.pfet_03v3_XWLNX2_0.D.n39 gf180mcu_ocd_ip__classab_buffer_0.se_folded_cascode_np_ab_0.pfet_03v3_XWLNX2_0.D.n74 4.5005
R990 gf180mcu_ocd_ip__classab_buffer_0.se_folded_cascode_np_ab_0.pfet_03v3_XWLNX2_0.D.n23 gf180mcu_ocd_ip__classab_buffer_0.se_folded_cascode_np_ab_0.pfet_03v3_XWLNX2_0.D.n1 4.5005
R991 gf180mcu_ocd_ip__classab_buffer_0.se_folded_cascode_np_ab_0.pfet_03v3_XWLNX2_0.D.n28 gf180mcu_ocd_ip__classab_buffer_0.se_folded_cascode_np_ab_0.pfet_03v3_XWLNX2_0.D.n73 4.5005
R992 gf180mcu_ocd_ip__classab_buffer_0.se_folded_cascode_np_ab_0.pfet_03v3_XWLNX2_0.D.n26 gf180mcu_ocd_ip__classab_buffer_0.se_folded_cascode_np_ab_0.pfet_03v3_XWLNX2_0.D.n24 4.5005
R993 gf180mcu_ocd_ip__classab_buffer_0.se_folded_cascode_np_ab_0.pfet_03v3_XWLNX2_0.D.n25 gf180mcu_ocd_ip__classab_buffer_0.se_folded_cascode_np_ab_0.pfet_03v3_XWLNX2_0.D.n72 4.5005
R994 gf180mcu_ocd_ip__classab_buffer_0.se_folded_cascode_np_ab_0.pfet_03v3_XWLNX2_0.D.n37 gf180mcu_ocd_ip__classab_buffer_0.se_folded_cascode_np_ab_0.pfet_03v3_XWLNX2_0.D.n30 4.5005
R995 gf180mcu_ocd_ip__classab_buffer_0.se_folded_cascode_np_ab_0.pfet_03v3_XWLNX2_0.D.n44 gf180mcu_ocd_ip__classab_buffer_0.se_folded_cascode_np_ab_0.pfet_03v3_XWLNX2_0.D.n8 4.5005
R996 gf180mcu_ocd_ip__classab_buffer_0.se_folded_cascode_np_ab_0.pfet_03v3_XWLNX2_0.D.n14 gf180mcu_ocd_ip__classab_buffer_0.se_folded_cascode_np_ab_0.pfet_03v3_XWLNX2_0.D.n11 4.5005
R997 gf180mcu_ocd_ip__classab_buffer_0.se_folded_cascode_np_ab_0.pfet_03v3_XWLNX2_0.D.n43 gf180mcu_ocd_ip__classab_buffer_0.se_folded_cascode_np_ab_0.pfet_03v3_XWLNX2_0.D.n10 4.5005
R998 gf180mcu_ocd_ip__classab_buffer_0.se_folded_cascode_np_ab_0.pfet_03v3_XWLNX2_0.D.n42 gf180mcu_ocd_ip__classab_buffer_0.se_folded_cascode_np_ab_0.pfet_03v3_XWLNX2_0.D.n9 4.5005
R999 gf180mcu_ocd_ip__classab_buffer_0.se_folded_cascode_np_ab_0.pfet_03v3_XWLNX2_0.D.n24 gf180mcu_ocd_ip__classab_buffer_0.se_folded_cascode_np_ab_0.pfet_03v3_XWLNX2_0.D.n75 4.5005
R1000 gf180mcu_ocd_ip__classab_buffer_0.se_folded_cascode_np_ab_0.pfet_03v3_XWLNX2_0.D.n2 gf180mcu_ocd_ip__classab_buffer_0.se_folded_cascode_np_ab_0.pfet_03v3_XWLNX2_0.D.n1 4.5005
R1001 gf180mcu_ocd_ip__classab_buffer_0.se_folded_cascode_np_ab_0.pfet_03v3_XWLNX2_0.D.n29 gf180mcu_ocd_ip__classab_buffer_0.se_folded_cascode_np_ab_0.pfet_03v3_XWLNX2_0.D.n28 4.5005
R1002 gf180mcu_ocd_ip__classab_buffer_0.se_folded_cascode_np_ab_0.pfet_03v3_XWLNX2_0.D gf180mcu_ocd_ip__classab_buffer_0.se_folded_cascode_np_ab_0.pfet_03v3_XWLNX2_0.D.t2 4.4205
R1003 gf180mcu_ocd_ip__classab_buffer_0.se_folded_cascode_np_ab_0.pfet_03v3_XWLNX2_0.D gf180mcu_ocd_ip__classab_buffer_0.se_folded_cascode_np_ab_0.pfet_03v3_XWLNX2_0.D.t5 4.4205
R1004 gf180mcu_ocd_ip__classab_buffer_0.se_folded_cascode_np_ab_0.pfet_03v3_XWLNX2_0.D gf180mcu_ocd_ip__classab_buffer_0.se_folded_cascode_np_ab_0.pfet_03v3_XWLNX2_0.D.t4 4.4205
R1005 gf180mcu_ocd_ip__classab_buffer_0.se_folded_cascode_np_ab_0.pfet_03v3_XWLNX2_0.D gf180mcu_ocd_ip__classab_buffer_0.se_folded_cascode_np_ab_0.pfet_03v3_XWLNX2_0.D.t13 4.4205
R1006 gf180mcu_ocd_ip__classab_buffer_0.se_folded_cascode_np_ab_0.pfet_03v3_XWLNX2_0.D gf180mcu_ocd_ip__classab_buffer_0.se_folded_cascode_np_ab_0.pfet_03v3_XWLNX2_0.D.t3 4.4205
R1007 gf180mcu_ocd_ip__classab_buffer_0.se_folded_cascode_np_ab_0.pfet_03v3_XWLNX2_0.D gf180mcu_ocd_ip__classab_buffer_0.se_folded_cascode_np_ab_0.pfet_03v3_XWLNX2_0.D.t12 4.4205
R1008 gf180mcu_ocd_ip__classab_buffer_0.se_folded_cascode_np_ab_0.pfet_03v3_XWLNX2_0.D gf180mcu_ocd_ip__classab_buffer_0.se_folded_cascode_np_ab_0.pfet_03v3_XWLNX2_0.D.t11 4.4205
R1009 gf180mcu_ocd_ip__classab_buffer_0.se_folded_cascode_np_ab_0.pfet_03v3_XWLNX2_0.D gf180mcu_ocd_ip__classab_buffer_0.se_folded_cascode_np_ab_0.pfet_03v3_XWLNX2_0.D.t6 4.4205
R1010 gf180mcu_ocd_ip__classab_buffer_0.se_folded_cascode_np_ab_0.pfet_03v3_XWLNX2_0.D gf180mcu_ocd_ip__classab_buffer_0.se_folded_cascode_np_ab_0.pfet_03v3_XWLNX2_0.D.t10 4.4205
R1011 gf180mcu_ocd_ip__classab_buffer_0.se_folded_cascode_np_ab_0.pfet_03v3_XWLNX2_0.D gf180mcu_ocd_ip__classab_buffer_0.se_folded_cascode_np_ab_0.pfet_03v3_XWLNX2_0.D.t0 4.4205
R1012 gf180mcu_ocd_ip__classab_buffer_0.se_folded_cascode_np_ab_0.pfet_03v3_XWLNX2_0.D gf180mcu_ocd_ip__classab_buffer_0.se_folded_cascode_np_ab_0.pfet_03v3_XWLNX2_0.D.t15 4.4205
R1013 gf180mcu_ocd_ip__classab_buffer_0.se_folded_cascode_np_ab_0.pfet_03v3_XWLNX2_0.D gf180mcu_ocd_ip__classab_buffer_0.se_folded_cascode_np_ab_0.pfet_03v3_XWLNX2_0.D.t7 4.4205
R1014 gf180mcu_ocd_ip__classab_buffer_0.se_folded_cascode_np_ab_0.pfet_03v3_XWLNX2_0.D gf180mcu_ocd_ip__classab_buffer_0.se_folded_cascode_np_ab_0.pfet_03v3_XWLNX2_0.D.t9 4.4205
R1015 gf180mcu_ocd_ip__classab_buffer_0.se_folded_cascode_np_ab_0.pfet_03v3_XWLNX2_0.D gf180mcu_ocd_ip__classab_buffer_0.se_folded_cascode_np_ab_0.pfet_03v3_XWLNX2_0.D.t1 4.4205
R1016 gf180mcu_ocd_ip__classab_buffer_0.se_folded_cascode_np_ab_0.pfet_03v3_XWLNX2_0.D gf180mcu_ocd_ip__classab_buffer_0.se_folded_cascode_np_ab_0.pfet_03v3_XWLNX2_0.D.t8 4.4205
R1017 gf180mcu_ocd_ip__classab_buffer_0.se_folded_cascode_np_ab_0.pfet_03v3_XWLNX2_0.D gf180mcu_ocd_ip__classab_buffer_0.se_folded_cascode_np_ab_0.pfet_03v3_XWLNX2_0.D.t14 4.4205
R1018 gf180mcu_ocd_ip__classab_buffer_0.se_folded_cascode_np_ab_0.pfet_03v3_XWLNX2_0.D.n62 gf180mcu_ocd_ip__classab_buffer_0.se_folded_cascode_np_ab_0.pfet_03v3_XWLNX2_0.D.n41 4.15288
R1019 gf180mcu_ocd_ip__classab_buffer_0.se_folded_cascode_np_ab_0.pfet_03v3_XWLNX2_0.D.n45 gf180mcu_ocd_ip__classab_buffer_0.se_folded_cascode_np_ab_0.pfet_03v3_XWLNX2_0.D.n41 4.14613
R1020 gf180mcu_ocd_ip__classab_buffer_0.se_folded_cascode_np_ab_0.pfet_03v3_XWLNX2_0.D.n29 gf180mcu_ocd_ip__classab_buffer_0.se_folded_cascode_np_ab_0.pfet_03v3_XWLNX2_0.D.n2 2.64907
R1021 gf180mcu_ocd_ip__classab_buffer_0.se_folded_cascode_np_ab_0.pfet_03v3_XWLNX2_0.D.n0 gf180mcu_ocd_ip__classab_buffer_0.se_folded_cascode_np_ab_0.pfet_03v3_XWLNX2_0.D.n20 2.64907
R1022 gf180mcu_ocd_ip__classab_buffer_0.se_folded_cascode_np_ab_0.pfet_03v3_XWLNX2_0.D gf180mcu_ocd_ip__classab_buffer_0.se_folded_cascode_np_ab_0.pfet_03v3_XWLNX2_0.D.t25 2.3945
R1023 gf180mcu_ocd_ip__classab_buffer_0.se_folded_cascode_np_ab_0.pfet_03v3_XWLNX2_0.D gf180mcu_ocd_ip__classab_buffer_0.se_folded_cascode_np_ab_0.pfet_03v3_XWLNX2_0.D.t24 2.3945
R1024 gf180mcu_ocd_ip__classab_buffer_0.se_folded_cascode_np_ab_0.pfet_03v3_XWLNX2_0.D gf180mcu_ocd_ip__classab_buffer_0.se_folded_cascode_np_ab_0.pfet_03v3_XWLNX2_0.D.t23 2.3945
R1025 gf180mcu_ocd_ip__classab_buffer_0.se_folded_cascode_np_ab_0.pfet_03v3_XWLNX2_0.D gf180mcu_ocd_ip__classab_buffer_0.se_folded_cascode_np_ab_0.pfet_03v3_XWLNX2_0.D.t22 2.3945
R1026 gf180mcu_ocd_ip__classab_buffer_0.se_folded_cascode_np_ab_0.pfet_03v3_XWLNX2_0.D gf180mcu_ocd_ip__classab_buffer_0.se_folded_cascode_np_ab_0.pfet_03v3_XWLNX2_0.D.t33 2.3945
R1027 gf180mcu_ocd_ip__classab_buffer_0.se_folded_cascode_np_ab_0.pfet_03v3_XWLNX2_0.D gf180mcu_ocd_ip__classab_buffer_0.se_folded_cascode_np_ab_0.pfet_03v3_XWLNX2_0.D.t32 2.3945
R1028 gf180mcu_ocd_ip__classab_buffer_0.se_folded_cascode_np_ab_0.pfet_03v3_XWLNX2_0.D gf180mcu_ocd_ip__classab_buffer_0.se_folded_cascode_np_ab_0.pfet_03v3_XWLNX2_0.D.t31 2.3945
R1029 gf180mcu_ocd_ip__classab_buffer_0.se_folded_cascode_np_ab_0.pfet_03v3_XWLNX2_0.D gf180mcu_ocd_ip__classab_buffer_0.se_folded_cascode_np_ab_0.pfet_03v3_XWLNX2_0.D.t30 2.3945
R1030 gf180mcu_ocd_ip__classab_buffer_0.se_folded_cascode_np_ab_0.pfet_03v3_XWLNX2_0.D gf180mcu_ocd_ip__classab_buffer_0.se_folded_cascode_np_ab_0.pfet_03v3_XWLNX2_0.D.t37 2.3945
R1031 gf180mcu_ocd_ip__classab_buffer_0.se_folded_cascode_np_ab_0.pfet_03v3_XWLNX2_0.D gf180mcu_ocd_ip__classab_buffer_0.se_folded_cascode_np_ab_0.pfet_03v3_XWLNX2_0.D.t36 2.3945
R1032 gf180mcu_ocd_ip__classab_buffer_0.se_folded_cascode_np_ab_0.pfet_03v3_XWLNX2_0.D gf180mcu_ocd_ip__classab_buffer_0.se_folded_cascode_np_ab_0.pfet_03v3_XWLNX2_0.D.t35 2.3945
R1033 gf180mcu_ocd_ip__classab_buffer_0.se_folded_cascode_np_ab_0.pfet_03v3_XWLNX2_0.D gf180mcu_ocd_ip__classab_buffer_0.se_folded_cascode_np_ab_0.pfet_03v3_XWLNX2_0.D.t34 2.3945
R1034 gf180mcu_ocd_ip__classab_buffer_0.se_folded_cascode_np_ab_0.pfet_03v3_XWLNX2_0.D gf180mcu_ocd_ip__classab_buffer_0.se_folded_cascode_np_ab_0.pfet_03v3_XWLNX2_0.D.t29 2.3945
R1035 gf180mcu_ocd_ip__classab_buffer_0.se_folded_cascode_np_ab_0.pfet_03v3_XWLNX2_0.D gf180mcu_ocd_ip__classab_buffer_0.se_folded_cascode_np_ab_0.pfet_03v3_XWLNX2_0.D.t28 2.3945
R1036 gf180mcu_ocd_ip__classab_buffer_0.se_folded_cascode_np_ab_0.pfet_03v3_XWLNX2_0.D gf180mcu_ocd_ip__classab_buffer_0.se_folded_cascode_np_ab_0.pfet_03v3_XWLNX2_0.D.t27 2.3945
R1037 gf180mcu_ocd_ip__classab_buffer_0.se_folded_cascode_np_ab_0.pfet_03v3_XWLNX2_0.D gf180mcu_ocd_ip__classab_buffer_0.se_folded_cascode_np_ab_0.pfet_03v3_XWLNX2_0.D.t26 2.3945
R1038 gf180mcu_ocd_ip__classab_buffer_0.se_folded_cascode_np_ab_0.pfet_03v3_XWLNX2_0.D.n59 gf180mcu_ocd_ip__classab_buffer_0.se_folded_cascode_np_ab_0.pfet_03v3_XWLNX2_0.D.n40 2.0905
R1039 gf180mcu_ocd_ip__classab_buffer_0.se_folded_cascode_np_ab_0.pfet_03v3_XWLNX2_0.D.n54 gf180mcu_ocd_ip__classab_buffer_0.se_folded_cascode_np_ab_0.pfet_03v3_XWLNX2_0.D.n13 2.00412
R1040 gf180mcu_ocd_ip__classab_buffer_0.se_folded_cascode_np_ab_0.pfet_03v3_XWLNX2_0.D.n14 gf180mcu_ocd_ip__classab_buffer_0.se_folded_cascode_np_ab_0.pfet_03v3_XWLNX2_0.D.n43 1.9985
R1041 gf180mcu_ocd_ip__classab_buffer_0.se_folded_cascode_np_ab_0.pfet_03v3_XWLNX2_0.D.n94 gf180mcu_ocd_ip__classab_buffer_0.se_folded_cascode_np_ab_0.pfet_03v3_XWLNX2_0.D.n3 1.83929
R1042 gf180mcu_ocd_ip__classab_buffer_0.se_folded_cascode_np_ab_0.pfet_03v3_XWLNX2_0.D.n5 gf180mcu_ocd_ip__classab_buffer_0.se_folded_cascode_np_ab_0.pfet_03v3_XWLNX2_0.D.n35 1.83929
R1043 gf180mcu_ocd_ip__classab_buffer_0.se_folded_cascode_np_ab_0.pfet_03v3_XWLNX2_0.D.n37 gf180mcu_ocd_ip__classab_buffer_0.se_folded_cascode_np_ab_0.pfet_03v3_XWLNX2_0.D.n8 1.83929
R1044 gf180mcu_ocd_ip__classab_buffer_0.se_folded_cascode_np_ab_0.pfet_03v3_XWLNX2_0.D.n78 gf180mcu_ocd_ip__classab_buffer_0.se_folded_cascode_np_ab_0.pfet_03v3_XWLNX2_0.D.n10 1.83929
R1045 gf180mcu_ocd_ip__classab_buffer_0.se_folded_cascode_np_ab_0.pfet_03v3_XWLNX2_0.D.n11 gf180mcu_ocd_ip__classab_buffer_0.se_folded_cascode_np_ab_0.pfet_03v3_XWLNX2_0.D.n80 1.83929
R1046 gf180mcu_ocd_ip__classab_buffer_0.se_folded_cascode_np_ab_0.pfet_03v3_XWLNX2_0.D.n12 gf180mcu_ocd_ip__classab_buffer_0.se_folded_cascode_np_ab_0.pfet_03v3_XWLNX2_0.D.n38 1.83929
R1047 gf180mcu_ocd_ip__classab_buffer_0.se_folded_cascode_np_ab_0.pfet_03v3_XWLNX2_0.D.n70 gf180mcu_ocd_ip__classab_buffer_0.se_folded_cascode_np_ab_0.pfet_03v3_XWLNX2_0.D.n7 1.83929
R1048 gf180mcu_ocd_ip__classab_buffer_0.se_folded_cascode_np_ab_0.pfet_03v3_XWLNX2_0.D.n9 gf180mcu_ocd_ip__classab_buffer_0.se_folded_cascode_np_ab_0.pfet_03v3_XWLNX2_0.D.n76 1.83929
R1049 gf180mcu_ocd_ip__classab_buffer_0.se_folded_cascode_np_ab_0.pfet_03v3_XWLNX2_0.D.n93 gf180mcu_ocd_ip__classab_buffer_0.se_folded_cascode_np_ab_0.pfet_03v3_XWLNX2_0.D.n58 1.82756
R1050 gf180mcu_ocd_ip__classab_buffer_0.se_folded_cascode_np_ab_0.pfet_03v3_XWLNX2_0.D.n82 gf180mcu_ocd_ip__classab_buffer_0.se_folded_cascode_np_ab_0.pfet_03v3_XWLNX2_0.D.n12 1.80166
R1051 gf180mcu_ocd_ip__classab_buffer_0.se_folded_cascode_np_ab_0.pfet_03v3_XWLNX2_0.D.n84 gf180mcu_ocd_ip__classab_buffer_0.se_folded_cascode_np_ab_0.pfet_03v3_XWLNX2_0.D.n11 1.80166
R1052 gf180mcu_ocd_ip__classab_buffer_0.se_folded_cascode_np_ab_0.pfet_03v3_XWLNX2_0.D.n85 gf180mcu_ocd_ip__classab_buffer_0.se_folded_cascode_np_ab_0.pfet_03v3_XWLNX2_0.D.n10 1.80166
R1053 gf180mcu_ocd_ip__classab_buffer_0.se_folded_cascode_np_ab_0.pfet_03v3_XWLNX2_0.D.n87 gf180mcu_ocd_ip__classab_buffer_0.se_folded_cascode_np_ab_0.pfet_03v3_XWLNX2_0.D.n9 1.80166
R1054 gf180mcu_ocd_ip__classab_buffer_0.se_folded_cascode_np_ab_0.pfet_03v3_XWLNX2_0.D.n89 gf180mcu_ocd_ip__classab_buffer_0.se_folded_cascode_np_ab_0.pfet_03v3_XWLNX2_0.D.n8 1.80166
R1055 gf180mcu_ocd_ip__classab_buffer_0.se_folded_cascode_np_ab_0.pfet_03v3_XWLNX2_0.D.n7 gf180mcu_ocd_ip__classab_buffer_0.se_folded_cascode_np_ab_0.pfet_03v3_XWLNX2_0.D.n6 1.80166
R1056 gf180mcu_ocd_ip__classab_buffer_0.se_folded_cascode_np_ab_0.pfet_03v3_XWLNX2_0.D.n5 gf180mcu_ocd_ip__classab_buffer_0.se_folded_cascode_np_ab_0.pfet_03v3_XWLNX2_0.D.n4 1.80166
R1057 gf180mcu_ocd_ip__classab_buffer_0.se_folded_cascode_np_ab_0.pfet_03v3_XWLNX2_0.D.n61 gf180mcu_ocd_ip__classab_buffer_0.se_folded_cascode_np_ab_0.pfet_03v3_XWLNX2_0.D.n3 1.80166
R1058 gf180mcu_ocd_ip__classab_buffer_0.se_folded_cascode_np_ab_0.pfet_03v3_XWLNX2_0.D.n16 gf180mcu_ocd_ip__classab_buffer_0.se_folded_cascode_np_ab_0.pfet_03v3_XWLNX2_0.D.n79 1.68479
R1059 gf180mcu_ocd_ip__classab_buffer_0.se_folded_cascode_np_ab_0.pfet_03v3_XWLNX2_0.D.n15 gf180mcu_ocd_ip__classab_buffer_0.se_folded_cascode_np_ab_0.pfet_03v3_XWLNX2_0.D.n17 1.68479
R1060 gf180mcu_ocd_ip__classab_buffer_0.se_folded_cascode_np_ab_0.pfet_03v3_XWLNX2_0.D.n71 gf180mcu_ocd_ip__classab_buffer_0.se_folded_cascode_np_ab_0.pfet_03v3_XWLNX2_0.D.n19 1.68479
R1061 gf180mcu_ocd_ip__classab_buffer_0.se_folded_cascode_np_ab_0.pfet_03v3_XWLNX2_0.D.n95 gf180mcu_ocd_ip__classab_buffer_0.se_folded_cascode_np_ab_0.pfet_03v3_XWLNX2_0.D.n18 1.68479
R1062 gf180mcu_ocd_ip__classab_buffer_0.se_folded_cascode_np_ab_0.pfet_03v3_XWLNX2_0.D.n21 gf180mcu_ocd_ip__classab_buffer_0.se_folded_cascode_np_ab_0.pfet_03v3_XWLNX2_0.D.n63 1.68479
R1063 gf180mcu_ocd_ip__classab_buffer_0.se_folded_cascode_np_ab_0.pfet_03v3_XWLNX2_0.D.n22 gf180mcu_ocd_ip__classab_buffer_0.se_folded_cascode_np_ab_0.pfet_03v3_XWLNX2_0.D.n65 1.68479
R1064 gf180mcu_ocd_ip__classab_buffer_0.se_folded_cascode_np_ab_0.pfet_03v3_XWLNX2_0.D.n74 gf180mcu_ocd_ip__classab_buffer_0.se_folded_cascode_np_ab_0.pfet_03v3_XWLNX2_0.D.n23 1.68479
R1065 gf180mcu_ocd_ip__classab_buffer_0.se_folded_cascode_np_ab_0.pfet_03v3_XWLNX2_0.D.n73 gf180mcu_ocd_ip__classab_buffer_0.se_folded_cascode_np_ab_0.pfet_03v3_XWLNX2_0.D.n26 1.68479
R1066 gf180mcu_ocd_ip__classab_buffer_0.se_folded_cascode_np_ab_0.pfet_03v3_XWLNX2_0.D.n25 gf180mcu_ocd_ip__classab_buffer_0.se_folded_cascode_np_ab_0.pfet_03v3_XWLNX2_0.D.n27 1.68479
R1067 gf180mcu_ocd_ip__classab_buffer_0.se_folded_cascode_np_ab_0.pfet_03v3_XWLNX2_0.D.n68 gf180mcu_ocd_ip__classab_buffer_0.se_folded_cascode_np_ab_0.pfet_03v3_XWLNX2_0.D.n67 1.68479
R1068 gf180mcu_ocd_ip__classab_buffer_0.se_folded_cascode_np_ab_0.pfet_03v3_XWLNX2_0.D.n75 gf180mcu_ocd_ip__classab_buffer_0.se_folded_cascode_np_ab_0.pfet_03v3_XWLNX2_0.D.n30 1.68479
R1069 gf180mcu_ocd_ip__classab_buffer_0.se_folded_cascode_np_ab_0.pfet_03v3_XWLNX2_0.D.n69 gf180mcu_ocd_ip__classab_buffer_0.se_folded_cascode_np_ab_0.pfet_03v3_XWLNX2_0.D.n32 1.68479
R1070 gf180mcu_ocd_ip__classab_buffer_0.se_folded_cascode_np_ab_0.pfet_03v3_XWLNX2_0.D.n32 gf180mcu_ocd_ip__classab_buffer_0.se_folded_cascode_np_ab_0.pfet_03v3_XWLNX2_0.D.n31 1.68479
R1071 gf180mcu_ocd_ip__classab_buffer_0.se_folded_cascode_np_ab_0.pfet_03v3_XWLNX2_0.D.n69 gf180mcu_ocd_ip__classab_buffer_0.se_folded_cascode_np_ab_0.pfet_03v3_XWLNX2_0.D.n30 1.68479
R1072 gf180mcu_ocd_ip__classab_buffer_0.se_folded_cascode_np_ab_0.pfet_03v3_XWLNX2_0.D.n75 gf180mcu_ocd_ip__classab_buffer_0.se_folded_cascode_np_ab_0.pfet_03v3_XWLNX2_0.D.n29 1.68479
R1073 gf180mcu_ocd_ip__classab_buffer_0.se_folded_cascode_np_ab_0.pfet_03v3_XWLNX2_0.D.n68 gf180mcu_ocd_ip__classab_buffer_0.se_folded_cascode_np_ab_0.pfet_03v3_XWLNX2_0.D.n27 1.68479
R1074 gf180mcu_ocd_ip__classab_buffer_0.se_folded_cascode_np_ab_0.pfet_03v3_XWLNX2_0.D.n26 gf180mcu_ocd_ip__classab_buffer_0.se_folded_cascode_np_ab_0.pfet_03v3_XWLNX2_0.D.n25 1.68479
R1075 gf180mcu_ocd_ip__classab_buffer_0.se_folded_cascode_np_ab_0.pfet_03v3_XWLNX2_0.D.n73 gf180mcu_ocd_ip__classab_buffer_0.se_folded_cascode_np_ab_0.pfet_03v3_XWLNX2_0.D.n23 1.68479
R1076 gf180mcu_ocd_ip__classab_buffer_0.se_folded_cascode_np_ab_0.pfet_03v3_XWLNX2_0.D.n66 gf180mcu_ocd_ip__classab_buffer_0.se_folded_cascode_np_ab_0.pfet_03v3_XWLNX2_0.D.n22 1.68479
R1077 gf180mcu_ocd_ip__classab_buffer_0.se_folded_cascode_np_ab_0.pfet_03v3_XWLNX2_0.D.n65 gf180mcu_ocd_ip__classab_buffer_0.se_folded_cascode_np_ab_0.pfet_03v3_XWLNX2_0.D.n21 1.68479
R1078 gf180mcu_ocd_ip__classab_buffer_0.se_folded_cascode_np_ab_0.pfet_03v3_XWLNX2_0.D.n63 gf180mcu_ocd_ip__classab_buffer_0.se_folded_cascode_np_ab_0.pfet_03v3_XWLNX2_0.D.n20 1.68479
R1079 gf180mcu_ocd_ip__classab_buffer_0.se_folded_cascode_np_ab_0.pfet_03v3_XWLNX2_0.D.n19 gf180mcu_ocd_ip__classab_buffer_0.se_folded_cascode_np_ab_0.pfet_03v3_XWLNX2_0.D.n18 1.68479
R1080 gf180mcu_ocd_ip__classab_buffer_0.se_folded_cascode_np_ab_0.pfet_03v3_XWLNX2_0.D.n71 gf180mcu_ocd_ip__classab_buffer_0.se_folded_cascode_np_ab_0.pfet_03v3_XWLNX2_0.D.n17 1.68479
R1081 gf180mcu_ocd_ip__classab_buffer_0.se_folded_cascode_np_ab_0.pfet_03v3_XWLNX2_0.D.n16 gf180mcu_ocd_ip__classab_buffer_0.se_folded_cascode_np_ab_0.pfet_03v3_XWLNX2_0.D.n15 1.68479
R1082 gf180mcu_ocd_ip__classab_buffer_0.se_folded_cascode_np_ab_0.pfet_03v3_XWLNX2_0.D gf180mcu_ocd_ip__classab_buffer_0.se_folded_cascode_np_ab_0.pfet_03v3_XWLNX2_0.D.n58 1.59991
R1083 gf180mcu_ocd_ip__classab_buffer_0.se_folded_cascode_np_ab_0.pfet_03v3_XWLNX2_0.D.n39 gf180mcu_ocd_ip__classab_buffer_0.se_folded_cascode_np_ab_0.pfet_03v3_XWLNX2_0.D.n38 1.43208
R1084 gf180mcu_ocd_ip__classab_buffer_0.se_folded_cascode_np_ab_0.pfet_03v3_XWLNX2_0.D.n80 gf180mcu_ocd_ip__classab_buffer_0.se_folded_cascode_np_ab_0.pfet_03v3_XWLNX2_0.D.n1 1.43208
R1085 gf180mcu_ocd_ip__classab_buffer_0.se_folded_cascode_np_ab_0.pfet_03v3_XWLNX2_0.D.n78 gf180mcu_ocd_ip__classab_buffer_0.se_folded_cascode_np_ab_0.pfet_03v3_XWLNX2_0.D.n28 1.43208
R1086 gf180mcu_ocd_ip__classab_buffer_0.se_folded_cascode_np_ab_0.pfet_03v3_XWLNX2_0.D.n76 gf180mcu_ocd_ip__classab_buffer_0.se_folded_cascode_np_ab_0.pfet_03v3_XWLNX2_0.D.n24 1.43208
R1087 gf180mcu_ocd_ip__classab_buffer_0.se_folded_cascode_np_ab_0.pfet_03v3_XWLNX2_0.D.n72 gf180mcu_ocd_ip__classab_buffer_0.se_folded_cascode_np_ab_0.pfet_03v3_XWLNX2_0.D.n37 1.43208
R1088 gf180mcu_ocd_ip__classab_buffer_0.se_folded_cascode_np_ab_0.pfet_03v3_XWLNX2_0.D.n70 gf180mcu_ocd_ip__classab_buffer_0.se_folded_cascode_np_ab_0.pfet_03v3_XWLNX2_0.D.n36 1.43208
R1089 gf180mcu_ocd_ip__classab_buffer_0.se_folded_cascode_np_ab_0.pfet_03v3_XWLNX2_0.D.n35 gf180mcu_ocd_ip__classab_buffer_0.se_folded_cascode_np_ab_0.pfet_03v3_XWLNX2_0.D.n34 1.43208
R1090 gf180mcu_ocd_ip__classab_buffer_0.se_folded_cascode_np_ab_0.pfet_03v3_XWLNX2_0.D.n94 gf180mcu_ocd_ip__classab_buffer_0.se_folded_cascode_np_ab_0.pfet_03v3_XWLNX2_0.D.n33 1.43208
R1091 gf180mcu_ocd_ip__classab_buffer_0.se_folded_cascode_np_ab_0.pfet_03v3_XWLNX2_0.D.t19 gf180mcu_ocd_ip__classab_buffer_0.se_folded_cascode_np_ab_0.pfet_03v3_XWLNX2_0.D.t16 1.32911
R1092 gf180mcu_ocd_ip__classab_buffer_0.se_folded_cascode_np_ab_0.pfet_03v3_XWLNX2_0.D.n58 gf180mcu_ocd_ip__classab_buffer_0.se_folded_cascode_np_ab_0.pfet_03v3_XWLNX2_0.D.t19 1.30442
R1093 gf180mcu_ocd_ip__classab_buffer_0.se_folded_cascode_np_ab_0.pfet_03v3_XWLNX2_0.D.n97 gf180mcu_ocd_ip__classab_buffer_0.se_folded_cascode_np_ab_0.pfet_03v3_XWLNX2_0.D.n96 1.21383
R1094 gf180mcu_ocd_ip__classab_buffer_0.se_folded_cascode_np_ab_0.pfet_03v3_XWLNX2_0.D.n97 gf180mcu_ocd_ip__classab_buffer_0.se_folded_cascode_np_ab_0.pfet_03v3_XWLNX2_0.D.t21 1.18258
R1095 gf180mcu_ocd_ip__classab_buffer_0.se_folded_cascode_np_ab_0.pfet_03v3_XWLNX2_0.D.n81 gf180mcu_ocd_ip__classab_buffer_0.se_folded_cascode_np_ab_0.pfet_03v3_XWLNX2_0.D.n51 1.1795
R1096 gf180mcu_ocd_ip__classab_buffer_0.se_folded_cascode_np_ab_0.pfet_03v3_XWLNX2_0.D.n77 gf180mcu_ocd_ip__classab_buffer_0.se_folded_cascode_np_ab_0.pfet_03v3_XWLNX2_0.D.n52 1.1795
R1097 gf180mcu_ocd_ip__classab_buffer_0.se_folded_cascode_np_ab_0.pfet_03v3_XWLNX2_0.D.n64 gf180mcu_ocd_ip__classab_buffer_0.se_folded_cascode_np_ab_0.pfet_03v3_XWLNX2_0.D.n53 1.1795
R1098 gf180mcu_ocd_ip__classab_buffer_0.se_folded_cascode_np_ab_0.pfet_03v3_XWLNX2_0.D.n93 gf180mcu_ocd_ip__classab_buffer_0.se_folded_cascode_np_ab_0.pfet_03v3_XWLNX2_0.D.n92 1.1795
R1099 gf180mcu_ocd_ip__classab_buffer_0.se_folded_cascode_np_ab_0.pfet_03v3_XWLNX2_0.D.n47 gf180mcu_ocd_ip__classab_buffer_0.se_folded_cascode_np_ab_0.pfet_03v3_XWLNX2_0.D.n83 1.1795
R1100 gf180mcu_ocd_ip__classab_buffer_0.se_folded_cascode_np_ab_0.pfet_03v3_XWLNX2_0.D.n48 gf180mcu_ocd_ip__classab_buffer_0.se_folded_cascode_np_ab_0.pfet_03v3_XWLNX2_0.D.n86 1.1795
R1101 gf180mcu_ocd_ip__classab_buffer_0.se_folded_cascode_np_ab_0.pfet_03v3_XWLNX2_0.D.n50 gf180mcu_ocd_ip__classab_buffer_0.se_folded_cascode_np_ab_0.pfet_03v3_XWLNX2_0.D.n90 1.1795
R1102 gf180mcu_ocd_ip__classab_buffer_0.se_folded_cascode_np_ab_0.pfet_03v3_XWLNX2_0.D.n49 gf180mcu_ocd_ip__classab_buffer_0.se_folded_cascode_np_ab_0.pfet_03v3_XWLNX2_0.D.n62 1.1795
R1103 gf180mcu_ocd_ip__classab_buffer_0.se_folded_cascode_np_ab_0.pfet_03v3_XWLNX2_0.D.n56 gf180mcu_ocd_ip__classab_buffer_0.se_folded_cascode_np_ab_0.pfet_03v3_XWLNX2_0.D.n88 1.1795
R1104 gf180mcu_ocd_ip__classab_buffer_0.se_folded_cascode_np_ab_0.pfet_03v3_XWLNX2_0.D.n57 gf180mcu_ocd_ip__classab_buffer_0.se_folded_cascode_np_ab_0.pfet_03v3_XWLNX2_0.D.n55 1.1795
R1105 gf180mcu_ocd_ip__classab_buffer_0.se_folded_cascode_np_ab_0.pfet_03v3_XWLNX2_0.D.n42 gf180mcu_ocd_ip__classab_buffer_0.se_folded_cascode_np_ab_0.pfet_03v3_XWLNX2_0.D.n44 1.1795
R1106 gf180mcu_ocd_ip__classab_buffer_0.se_folded_cascode_np_ab_0.pfet_03v3_XWLNX2_0.D.n46 gf180mcu_ocd_ip__classab_buffer_0.se_folded_cascode_np_ab_0.pfet_03v3_XWLNX2_0.D.n91 1.1795
R1107 gf180mcu_ocd_ip__classab_buffer_0.se_folded_cascode_np_ab_0.pfet_03v3_XWLNX2_0.D.n60 gf180mcu_ocd_ip__classab_buffer_0.se_folded_cascode_np_ab_0.pfet_03v3_XWLNX2_0.D.n57 1.1795
R1108 gf180mcu_ocd_ip__classab_buffer_0.se_folded_cascode_np_ab_0.pfet_03v3_XWLNX2_0.D.n56 gf180mcu_ocd_ip__classab_buffer_0.se_folded_cascode_np_ab_0.pfet_03v3_XWLNX2_0.D.n55 1.1795
R1109 gf180mcu_ocd_ip__classab_buffer_0.se_folded_cascode_np_ab_0.pfet_03v3_XWLNX2_0.D.n88 gf180mcu_ocd_ip__classab_buffer_0.se_folded_cascode_np_ab_0.pfet_03v3_XWLNX2_0.D.n54 1.1795
R1110 gf180mcu_ocd_ip__classab_buffer_0.se_folded_cascode_np_ab_0.pfet_03v3_XWLNX2_0.D.n92 gf180mcu_ocd_ip__classab_buffer_0.se_folded_cascode_np_ab_0.pfet_03v3_XWLNX2_0.D.n53 1.1795
R1111 gf180mcu_ocd_ip__classab_buffer_0.se_folded_cascode_np_ab_0.pfet_03v3_XWLNX2_0.D.n64 gf180mcu_ocd_ip__classab_buffer_0.se_folded_cascode_np_ab_0.pfet_03v3_XWLNX2_0.D.n52 1.1795
R1112 gf180mcu_ocd_ip__classab_buffer_0.se_folded_cascode_np_ab_0.pfet_03v3_XWLNX2_0.D.n77 gf180mcu_ocd_ip__classab_buffer_0.se_folded_cascode_np_ab_0.pfet_03v3_XWLNX2_0.D.n51 1.1795
R1113 gf180mcu_ocd_ip__classab_buffer_0.se_folded_cascode_np_ab_0.pfet_03v3_XWLNX2_0.D.n50 gf180mcu_ocd_ip__classab_buffer_0.se_folded_cascode_np_ab_0.pfet_03v3_XWLNX2_0.D.n49 1.1795
R1114 gf180mcu_ocd_ip__classab_buffer_0.se_folded_cascode_np_ab_0.pfet_03v3_XWLNX2_0.D.n90 gf180mcu_ocd_ip__classab_buffer_0.se_folded_cascode_np_ab_0.pfet_03v3_XWLNX2_0.D.n48 1.1795
R1115 gf180mcu_ocd_ip__classab_buffer_0.se_folded_cascode_np_ab_0.pfet_03v3_XWLNX2_0.D.n86 gf180mcu_ocd_ip__classab_buffer_0.se_folded_cascode_np_ab_0.pfet_03v3_XWLNX2_0.D.n47 1.1795
R1116 gf180mcu_ocd_ip__classab_buffer_0.se_folded_cascode_np_ab_0.pfet_03v3_XWLNX2_0.D.n46 gf180mcu_ocd_ip__classab_buffer_0.se_folded_cascode_np_ab_0.pfet_03v3_XWLNX2_0.D.n45 1.1795
R1117 gf180mcu_ocd_ip__classab_buffer_0.se_folded_cascode_np_ab_0.pfet_03v3_XWLNX2_0.D.n91 gf180mcu_ocd_ip__classab_buffer_0.se_folded_cascode_np_ab_0.pfet_03v3_XWLNX2_0.D.n44 1.1795
R1118 gf180mcu_ocd_ip__classab_buffer_0.se_folded_cascode_np_ab_0.pfet_03v3_XWLNX2_0.D.n43 gf180mcu_ocd_ip__classab_buffer_0.se_folded_cascode_np_ab_0.pfet_03v3_XWLNX2_0.D.n42 1.1795
R1119 gf180mcu_ocd_ip__classab_buffer_0.se_folded_cascode_np_ab_0.pfet_03v3_XWLNX2_0.D.n59 gf180mcu_ocd_ip__classab_buffer_0.se_folded_cascode_np_ab_0.pfet_03v3_XWLNX2_0.D.n41 1.11995
R1120 gf180mcu_ocd_ip__classab_buffer_0.se_folded_cascode_np_ab_0.pfet_03v3_XWLNX2_0.D.n59 gf180mcu_ocd_ip__classab_buffer_0.se_folded_cascode_np_ab_0.pfet_03v3_XWLNX2_0.D.n58 0.556901
R1121 gf180mcu_ocd_ip__classab_buffer_0.se_folded_cascode_np_ab_0.pfet_03v3_XWLNX2_0.D.n58 gf180mcu_ocd_ip__classab_buffer_0.se_folded_cascode_np_ab_0.pfet_03v3_XWLNX2_0.D 1.03066
R1122 gf180mcu_ocd_ip__classab_buffer_0.se_folded_cascode_np_ab_0.outa1p.n50 gf180mcu_ocd_ip__classab_buffer_0.se_folded_cascode_np_ab_0.outa1p 7.97568
R1123 gf180mcu_ocd_ip__classab_buffer_0.se_folded_cascode_np_ab_0.outa1p.n47 gf180mcu_ocd_ip__classab_buffer_0.se_folded_cascode_np_ab_0.outa1p 7.92425
R1124 gf180mcu_ocd_ip__classab_buffer_0.se_folded_cascode_np_ab_0.outa1p.n2 gf180mcu_ocd_ip__classab_buffer_0.se_folded_cascode_np_ab_0.outa1p 7.05639
R1125 gf180mcu_ocd_ip__classab_buffer_0.se_folded_cascode_np_ab_0.outa1p.n16 gf180mcu_ocd_ip__classab_buffer_0.se_folded_cascode_np_ab_0.outa1p 7.05639
R1126 gf180mcu_ocd_ip__classab_buffer_0.se_folded_cascode_np_ab_0.outa1p.n15 gf180mcu_ocd_ip__classab_buffer_0.se_folded_cascode_np_ab_0.outa1p 7.05639
R1127 gf180mcu_ocd_ip__classab_buffer_0.se_folded_cascode_np_ab_0.outa1p.n13 gf180mcu_ocd_ip__classab_buffer_0.se_folded_cascode_np_ab_0.outa1p 7.05639
R1128 gf180mcu_ocd_ip__classab_buffer_0.se_folded_cascode_np_ab_0.outa1p.n22 gf180mcu_ocd_ip__classab_buffer_0.se_folded_cascode_np_ab_0.outa1p 7.03068
R1129 gf180mcu_ocd_ip__classab_buffer_0.se_folded_cascode_np_ab_0.outa1p.n20 gf180mcu_ocd_ip__classab_buffer_0.se_folded_cascode_np_ab_0.outa1p 7.03068
R1130 gf180mcu_ocd_ip__classab_buffer_0.se_folded_cascode_np_ab_0.outa1p.n18 gf180mcu_ocd_ip__classab_buffer_0.se_folded_cascode_np_ab_0.outa1p 7.03068
R1131 gf180mcu_ocd_ip__classab_buffer_0.se_folded_cascode_np_ab_0.outa1p.n3 gf180mcu_ocd_ip__classab_buffer_0.se_folded_cascode_np_ab_0.outa1p 7.00496
R1132 gf180mcu_ocd_ip__classab_buffer_0.se_folded_cascode_np_ab_0.outa1p.n27 gf180mcu_ocd_ip__classab_buffer_0.se_folded_cascode_np_ab_0.outa1p 7.00496
R1133 gf180mcu_ocd_ip__classab_buffer_0.se_folded_cascode_np_ab_0.outa1p.n25 gf180mcu_ocd_ip__classab_buffer_0.se_folded_cascode_np_ab_0.outa1p 7.00496
R1134 gf180mcu_ocd_ip__classab_buffer_0.se_folded_cascode_np_ab_0.outa1p.n24 gf180mcu_ocd_ip__classab_buffer_0.se_folded_cascode_np_ab_0.outa1p 7.00496
R1135 gf180mcu_ocd_ip__classab_buffer_0.se_folded_cascode_np_ab_0.outa1p.n32 gf180mcu_ocd_ip__classab_buffer_0.se_folded_cascode_np_ab_0.outa1p 6.97925
R1136 gf180mcu_ocd_ip__classab_buffer_0.se_folded_cascode_np_ab_0.outa1p.n30 gf180mcu_ocd_ip__classab_buffer_0.se_folded_cascode_np_ab_0.outa1p 6.97925
R1137 gf180mcu_ocd_ip__classab_buffer_0.se_folded_cascode_np_ab_0.outa1p.n29 gf180mcu_ocd_ip__classab_buffer_0.se_folded_cascode_np_ab_0.outa1p 6.97925
R1138 gf180mcu_ocd_ip__classab_buffer_0.se_folded_cascode_np_ab_0.outa1p.n17 gf180mcu_ocd_ip__classab_buffer_0.se_folded_cascode_np_ab_0.outa1p.n39 6.18479
R1139 gf180mcu_ocd_ip__classab_buffer_0.se_folded_cascode_np_ab_0.outa1p.n23 gf180mcu_ocd_ip__classab_buffer_0.se_folded_cascode_np_ab_0.outa1p.n54 6.18479
R1140 gf180mcu_ocd_ip__classab_buffer_0.se_folded_cascode_np_ab_0.outa1p.n8 gf180mcu_ocd_ip__classab_buffer_0.se_folded_cascode_np_ab_0.outa1p 6.0976
R1141 gf180mcu_ocd_ip__classab_buffer_0.se_folded_cascode_np_ab_0.outa1p gf180mcu_ocd_ip__classab_buffer_0.se_folded_cascode_np_ab_0.outa1p.n0 5.97291
R1142 gf180mcu_ocd_ip__classab_buffer_0.se_folded_cascode_np_ab_0.outa1p.n39 gf180mcu_ocd_ip__classab_buffer_0.se_folded_cascode_np_ab_0.outa1p.n13 5.4455
R1143 gf180mcu_ocd_ip__classab_buffer_0.se_folded_cascode_np_ab_0.outa1p.n24 gf180mcu_ocd_ip__classab_buffer_0.se_folded_cascode_np_ab_0.outa1p.n23 5.4455
R1144 gf180mcu_ocd_ip__classab_buffer_0.se_folded_cascode_np_ab_0.outa1p.n9 gf180mcu_ocd_ip__classab_buffer_0.se_folded_cascode_np_ab_0.outa1p 5.3884
R1145 gf180mcu_ocd_ip__classab_buffer_0.se_folded_cascode_np_ab_0.outa1p.n9 gf180mcu_ocd_ip__classab_buffer_0.se_folded_cascode_np_ab_0.outa1p 5.37316
R1146 gf180mcu_ocd_ip__classab_buffer_0.se_folded_cascode_np_ab_0.outa1p.n1 gf180mcu_ocd_ip__classab_buffer_0.se_folded_cascode_np_ab_0.outa1p 5.34293
R1147 gf180mcu_ocd_ip__classab_buffer_0.se_folded_cascode_np_ab_0.outa1p.n9 gf180mcu_ocd_ip__classab_buffer_0.se_folded_cascode_np_ab_0.outa1p 5.3305
R1148 gf180mcu_ocd_ip__classab_buffer_0.se_folded_cascode_np_ab_0.outa1p.n10 gf180mcu_ocd_ip__classab_buffer_0.se_folded_cascode_np_ab_0.outa1p 5.32525
R1149 gf180mcu_ocd_ip__classab_buffer_0.se_folded_cascode_np_ab_0.outa1p.n10 gf180mcu_ocd_ip__classab_buffer_0.se_folded_cascode_np_ab_0.outa1p 5.32487
R1150 gf180mcu_ocd_ip__classab_buffer_0.se_folded_cascode_np_ab_0.outa1p.n1 gf180mcu_ocd_ip__classab_buffer_0.se_folded_cascode_np_ab_0.outa1p 5.32487
R1151 gf180mcu_ocd_ip__classab_buffer_0.se_folded_cascode_np_ab_0.outa1p.n8 gf180mcu_ocd_ip__classab_buffer_0.se_folded_cascode_np_ab_0.outa1p 5.32291
R1152 gf180mcu_ocd_ip__classab_buffer_0.se_folded_cascode_np_ab_0.outa1p.n0 gf180mcu_ocd_ip__classab_buffer_0.se_folded_cascode_np_ab_0.outa1p 5.30561
R1153 gf180mcu_ocd_ip__classab_buffer_0.se_folded_cascode_np_ab_0.outa1p.n34 gf180mcu_ocd_ip__classab_buffer_0.se_folded_cascode_np_ab_0.outa1p.n2 5.23979
R1154 gf180mcu_ocd_ip__classab_buffer_0.se_folded_cascode_np_ab_0.outa1p.n33 gf180mcu_ocd_ip__classab_buffer_0.se_folded_cascode_np_ab_0.outa1p.n3 5.23979
R1155 gf180mcu_ocd_ip__classab_buffer_0.se_folded_cascode_np_ab_0.outa1p.n42 gf180mcu_ocd_ip__classab_buffer_0.se_folded_cascode_np_ab_0.outa1p 4.51897
R1156 gf180mcu_ocd_ip__classab_buffer_0.se_folded_cascode_np_ab_0.outa1p.n44 gf180mcu_ocd_ip__classab_buffer_0.se_folded_cascode_np_ab_0.outa1p 4.51486
R1157 gf180mcu_ocd_ip__classab_buffer_0.se_folded_cascode_np_ab_0.outa1p.n47 gf180mcu_ocd_ip__classab_buffer_0.se_folded_cascode_np_ab_0.outa1p.n33 4.5005
R1158 gf180mcu_ocd_ip__classab_buffer_0.se_folded_cascode_np_ab_0.outa1p.n34 gf180mcu_ocd_ip__classab_buffer_0.se_folded_cascode_np_ab_0.outa1p.n50 4.5005
R1159 gf180mcu_ocd_ip__classab_buffer_0.se_folded_cascode_np_ab_0.outa1p.n35 gf180mcu_ocd_ip__classab_buffer_0.se_folded_cascode_np_ab_0.outa1p.n32 4.5005
R1160 gf180mcu_ocd_ip__classab_buffer_0.se_folded_cascode_np_ab_0.outa1p.n3 gf180mcu_ocd_ip__classab_buffer_0.se_folded_cascode_np_ab_0.outa1p.n35 4.5005
R1161 gf180mcu_ocd_ip__classab_buffer_0.se_folded_cascode_np_ab_0.outa1p.n22 gf180mcu_ocd_ip__classab_buffer_0.se_folded_cascode_np_ab_0.outa1p.n21 4.5005
R1162 gf180mcu_ocd_ip__classab_buffer_0.se_folded_cascode_np_ab_0.outa1p.n2 gf180mcu_ocd_ip__classab_buffer_0.se_folded_cascode_np_ab_0.outa1p.n21 4.5005
R1163 gf180mcu_ocd_ip__classab_buffer_0.se_folded_cascode_np_ab_0.outa1p.n41 gf180mcu_ocd_ip__classab_buffer_0.se_folded_cascode_np_ab_0.outa1p.n15 4.5005
R1164 gf180mcu_ocd_ip__classab_buffer_0.se_folded_cascode_np_ab_0.outa1p.n52 gf180mcu_ocd_ip__classab_buffer_0.se_folded_cascode_np_ab_0.outa1p.n40 4.5005
R1165 gf180mcu_ocd_ip__classab_buffer_0.se_folded_cascode_np_ab_0.outa1p.n13 gf180mcu_ocd_ip__classab_buffer_0.se_folded_cascode_np_ab_0.outa1p.n37 4.5005
R1166 gf180mcu_ocd_ip__classab_buffer_0.se_folded_cascode_np_ab_0.outa1p.n14 gf180mcu_ocd_ip__classab_buffer_0.se_folded_cascode_np_ab_0.outa1p.n5 4.5005
R1167 gf180mcu_ocd_ip__classab_buffer_0.se_folded_cascode_np_ab_0.outa1p.n36 gf180mcu_ocd_ip__classab_buffer_0.se_folded_cascode_np_ab_0.outa1p.n16 4.5005
R1168 gf180mcu_ocd_ip__classab_buffer_0.se_folded_cascode_np_ab_0.outa1p.n31 gf180mcu_ocd_ip__classab_buffer_0.se_folded_cascode_np_ab_0.outa1p.n26 4.5005
R1169 gf180mcu_ocd_ip__classab_buffer_0.se_folded_cascode_np_ab_0.outa1p.n27 gf180mcu_ocd_ip__classab_buffer_0.se_folded_cascode_np_ab_0.outa1p.n26 4.5005
R1170 gf180mcu_ocd_ip__classab_buffer_0.se_folded_cascode_np_ab_0.outa1p.n51 gf180mcu_ocd_ip__classab_buffer_0.se_folded_cascode_np_ab_0.outa1p.n36 4.5005
R1171 gf180mcu_ocd_ip__classab_buffer_0.se_folded_cascode_np_ab_0.outa1p.n41 gf180mcu_ocd_ip__classab_buffer_0.se_folded_cascode_np_ab_0.outa1p.n19 4.5005
R1172 gf180mcu_ocd_ip__classab_buffer_0.se_folded_cascode_np_ab_0.outa1p.n40 gf180mcu_ocd_ip__classab_buffer_0.se_folded_cascode_np_ab_0.outa1p.n20 4.5005
R1173 gf180mcu_ocd_ip__classab_buffer_0.se_folded_cascode_np_ab_0.outa1p.n17 gf180mcu_ocd_ip__classab_buffer_0.se_folded_cascode_np_ab_0.outa1p.n37 4.5005
R1174 gf180mcu_ocd_ip__classab_buffer_0.se_folded_cascode_np_ab_0.outa1p.n5 gf180mcu_ocd_ip__classab_buffer_0.se_folded_cascode_np_ab_0.outa1p.n18 4.5005
R1175 gf180mcu_ocd_ip__classab_buffer_0.se_folded_cascode_np_ab_0.outa1p.n29 gf180mcu_ocd_ip__classab_buffer_0.se_folded_cascode_np_ab_0.outa1p.n28 4.5005
R1176 gf180mcu_ocd_ip__classab_buffer_0.se_folded_cascode_np_ab_0.outa1p.n53 gf180mcu_ocd_ip__classab_buffer_0.se_folded_cascode_np_ab_0.outa1p.n28 4.5005
R1177 gf180mcu_ocd_ip__classab_buffer_0.se_folded_cascode_np_ab_0.outa1p.n12 gf180mcu_ocd_ip__classab_buffer_0.se_folded_cascode_np_ab_0.outa1p.n25 4.5005
R1178 gf180mcu_ocd_ip__classab_buffer_0.se_folded_cascode_np_ab_0.outa1p.n48 gf180mcu_ocd_ip__classab_buffer_0.se_folded_cascode_np_ab_0.outa1p.n11 4.5005
R1179 gf180mcu_ocd_ip__classab_buffer_0.se_folded_cascode_np_ab_0.outa1p.n38 gf180mcu_ocd_ip__classab_buffer_0.se_folded_cascode_np_ab_0.outa1p.n24 4.5005
R1180 gf180mcu_ocd_ip__classab_buffer_0.se_folded_cascode_np_ab_0.outa1p.n54 gf180mcu_ocd_ip__classab_buffer_0.se_folded_cascode_np_ab_0.outa1p.n38 4.5005
R1181 gf180mcu_ocd_ip__classab_buffer_0.se_folded_cascode_np_ab_0.outa1p.n12 gf180mcu_ocd_ip__classab_buffer_0.se_folded_cascode_np_ab_0.outa1p.n49 4.5005
R1182 gf180mcu_ocd_ip__classab_buffer_0.se_folded_cascode_np_ab_0.outa1p.n11 gf180mcu_ocd_ip__classab_buffer_0.se_folded_cascode_np_ab_0.outa1p.n30 4.5005
R1183 gf180mcu_ocd_ip__classab_buffer_0.se_folded_cascode_np_ab_0.outa1p gf180mcu_ocd_ip__classab_buffer_0.se_folded_cascode_np_ab_0.outa1p.t17 4.4205
R1184 gf180mcu_ocd_ip__classab_buffer_0.se_folded_cascode_np_ab_0.outa1p gf180mcu_ocd_ip__classab_buffer_0.se_folded_cascode_np_ab_0.outa1p.t16 4.4205
R1185 gf180mcu_ocd_ip__classab_buffer_0.se_folded_cascode_np_ab_0.outa1p gf180mcu_ocd_ip__classab_buffer_0.se_folded_cascode_np_ab_0.outa1p.t15 4.4205
R1186 gf180mcu_ocd_ip__classab_buffer_0.se_folded_cascode_np_ab_0.outa1p gf180mcu_ocd_ip__classab_buffer_0.se_folded_cascode_np_ab_0.outa1p.t13 4.4205
R1187 gf180mcu_ocd_ip__classab_buffer_0.se_folded_cascode_np_ab_0.outa1p gf180mcu_ocd_ip__classab_buffer_0.se_folded_cascode_np_ab_0.outa1p.t12 4.4205
R1188 gf180mcu_ocd_ip__classab_buffer_0.se_folded_cascode_np_ab_0.outa1p gf180mcu_ocd_ip__classab_buffer_0.se_folded_cascode_np_ab_0.outa1p.t11 4.4205
R1189 gf180mcu_ocd_ip__classab_buffer_0.se_folded_cascode_np_ab_0.outa1p gf180mcu_ocd_ip__classab_buffer_0.se_folded_cascode_np_ab_0.outa1p.t10 4.4205
R1190 gf180mcu_ocd_ip__classab_buffer_0.se_folded_cascode_np_ab_0.outa1p gf180mcu_ocd_ip__classab_buffer_0.se_folded_cascode_np_ab_0.outa1p.t9 4.4205
R1191 gf180mcu_ocd_ip__classab_buffer_0.se_folded_cascode_np_ab_0.outa1p gf180mcu_ocd_ip__classab_buffer_0.se_folded_cascode_np_ab_0.outa1p.t8 4.4205
R1192 gf180mcu_ocd_ip__classab_buffer_0.se_folded_cascode_np_ab_0.outa1p gf180mcu_ocd_ip__classab_buffer_0.se_folded_cascode_np_ab_0.outa1p.t7 4.4205
R1193 gf180mcu_ocd_ip__classab_buffer_0.se_folded_cascode_np_ab_0.outa1p gf180mcu_ocd_ip__classab_buffer_0.se_folded_cascode_np_ab_0.outa1p.t6 4.4205
R1194 gf180mcu_ocd_ip__classab_buffer_0.se_folded_cascode_np_ab_0.outa1p gf180mcu_ocd_ip__classab_buffer_0.se_folded_cascode_np_ab_0.outa1p.t5 4.4205
R1195 gf180mcu_ocd_ip__classab_buffer_0.se_folded_cascode_np_ab_0.outa1p gf180mcu_ocd_ip__classab_buffer_0.se_folded_cascode_np_ab_0.outa1p.t4 4.4205
R1196 gf180mcu_ocd_ip__classab_buffer_0.se_folded_cascode_np_ab_0.outa1p gf180mcu_ocd_ip__classab_buffer_0.se_folded_cascode_np_ab_0.outa1p.t3 4.4205
R1197 gf180mcu_ocd_ip__classab_buffer_0.se_folded_cascode_np_ab_0.outa1p gf180mcu_ocd_ip__classab_buffer_0.se_folded_cascode_np_ab_0.outa1p.t2 4.4205
R1198 gf180mcu_ocd_ip__classab_buffer_0.se_folded_cascode_np_ab_0.outa1p gf180mcu_ocd_ip__classab_buffer_0.se_folded_cascode_np_ab_0.outa1p.t20 4.4205
R1199 gf180mcu_ocd_ip__classab_buffer_0.se_folded_cascode_np_ab_0.outa1p gf180mcu_ocd_ip__classab_buffer_0.se_folded_cascode_np_ab_0.outa1p.t35 4.4205
R1200 gf180mcu_ocd_ip__classab_buffer_0.se_folded_cascode_np_ab_0.outa1p gf180mcu_ocd_ip__classab_buffer_0.se_folded_cascode_np_ab_0.outa1p.t14 4.4205
R1201 gf180mcu_ocd_ip__classab_buffer_0.se_folded_cascode_np_ab_0.outa1p gf180mcu_ocd_ip__classab_buffer_0.se_folded_cascode_np_ab_0.outa1p.t22 4.4205
R1202 gf180mcu_ocd_ip__classab_buffer_0.se_folded_cascode_np_ab_0.outa1p gf180mcu_ocd_ip__classab_buffer_0.se_folded_cascode_np_ab_0.outa1p.t0 4.4205
R1203 gf180mcu_ocd_ip__classab_buffer_0.se_folded_cascode_np_ab_0.outa1p gf180mcu_ocd_ip__classab_buffer_0.se_folded_cascode_np_ab_0.outa1p.t33 4.4205
R1204 gf180mcu_ocd_ip__classab_buffer_0.se_folded_cascode_np_ab_0.outa1p gf180mcu_ocd_ip__classab_buffer_0.se_folded_cascode_np_ab_0.outa1p.t19 4.4205
R1205 gf180mcu_ocd_ip__classab_buffer_0.se_folded_cascode_np_ab_0.outa1p gf180mcu_ocd_ip__classab_buffer_0.se_folded_cascode_np_ab_0.outa1p.t31 4.4205
R1206 gf180mcu_ocd_ip__classab_buffer_0.se_folded_cascode_np_ab_0.outa1p gf180mcu_ocd_ip__classab_buffer_0.se_folded_cascode_np_ab_0.outa1p.t18 4.4205
R1207 gf180mcu_ocd_ip__classab_buffer_0.se_folded_cascode_np_ab_0.outa1p gf180mcu_ocd_ip__classab_buffer_0.se_folded_cascode_np_ab_0.outa1p.t32 4.4205
R1208 gf180mcu_ocd_ip__classab_buffer_0.se_folded_cascode_np_ab_0.outa1p gf180mcu_ocd_ip__classab_buffer_0.se_folded_cascode_np_ab_0.outa1p.t1 4.4205
R1209 gf180mcu_ocd_ip__classab_buffer_0.se_folded_cascode_np_ab_0.outa1p gf180mcu_ocd_ip__classab_buffer_0.se_folded_cascode_np_ab_0.outa1p.t34 4.4205
R1210 gf180mcu_ocd_ip__classab_buffer_0.se_folded_cascode_np_ab_0.outa1p gf180mcu_ocd_ip__classab_buffer_0.se_folded_cascode_np_ab_0.outa1p.t21 4.4205
R1211 gf180mcu_ocd_ip__classab_buffer_0.se_folded_cascode_np_ab_0.outa1p gf180mcu_ocd_ip__classab_buffer_0.se_folded_cascode_np_ab_0.outa1p.n45 3.89455
R1212 gf180mcu_ocd_ip__classab_buffer_0.se_folded_cascode_np_ab_0.outa1p.n43 gf180mcu_ocd_ip__classab_buffer_0.se_folded_cascode_np_ab_0.outa1p 3.89455
R1213 gf180mcu_ocd_ip__classab_buffer_0.se_folded_cascode_np_ab_0.outa1p.n43 gf180mcu_ocd_ip__classab_buffer_0.se_folded_cascode_np_ab_0.outa1p 3.89455
R1214 gf180mcu_ocd_ip__classab_buffer_0.se_folded_cascode_np_ab_0.outa1p.n42 gf180mcu_ocd_ip__classab_buffer_0.se_folded_cascode_np_ab_0.outa1p 3.89455
R1215 gf180mcu_ocd_ip__classab_buffer_0.se_folded_cascode_np_ab_0.outa1p.n45 gf180mcu_ocd_ip__classab_buffer_0.se_folded_cascode_np_ab_0.outa1p 3.89455
R1216 gf180mcu_ocd_ip__classab_buffer_0.se_folded_cascode_np_ab_0.outa1p.n44 gf180mcu_ocd_ip__classab_buffer_0.se_folded_cascode_np_ab_0.outa1p 3.89455
R1217 gf180mcu_ocd_ip__classab_buffer_0.se_folded_cascode_np_ab_0.outa1p.n45 gf180mcu_ocd_ip__classab_buffer_0.se_folded_cascode_np_ab_0.outa1p 3.7368
R1218 gf180mcu_ocd_ip__classab_buffer_0.se_folded_cascode_np_ab_0.outa1p.n7 gf180mcu_ocd_ip__classab_buffer_0.se_folded_cascode_np_ab_0.outa1p.n34 3.60275
R1219 gf180mcu_ocd_ip__classab_buffer_0.se_folded_cascode_np_ab_0.outa1p gf180mcu_ocd_ip__classab_buffer_0.se_folded_cascode_np_ab_0.outa1p.n43 3.44283
R1220 gf180mcu_ocd_ip__classab_buffer_0.se_folded_cascode_np_ab_0.outa1p.n35 gf180mcu_ocd_ip__classab_buffer_0.se_folded_cascode_np_ab_0.outa1p.n10 3.11032
R1221 gf180mcu_ocd_ip__classab_buffer_0.se_folded_cascode_np_ab_0.outa1p.n11 gf180mcu_ocd_ip__classab_buffer_0.se_folded_cascode_np_ab_0.outa1p 3.09298
R1222 gf180mcu_ocd_ip__classab_buffer_0.se_folded_cascode_np_ab_0.outa1p.n38 gf180mcu_ocd_ip__classab_buffer_0.se_folded_cascode_np_ab_0.outa1p.n1 3.08294
R1223 gf180mcu_ocd_ip__classab_buffer_0.se_folded_cascode_np_ab_0.outa1p.n12 gf180mcu_ocd_ip__classab_buffer_0.se_folded_cascode_np_ab_0.outa1p 3.07487
R1224 gf180mcu_ocd_ip__classab_buffer_0.se_folded_cascode_np_ab_0.outa1p.n26 gf180mcu_ocd_ip__classab_buffer_0.se_folded_cascode_np_ab_0.outa1p.n10 3.05889
R1225 gf180mcu_ocd_ip__classab_buffer_0.se_folded_cascode_np_ab_0.outa1p.n9 gf180mcu_ocd_ip__classab_buffer_0.se_folded_cascode_np_ab_0.outa1p.n33 3.03563
R1226 gf180mcu_ocd_ip__classab_buffer_0.se_folded_cascode_np_ab_0.outa1p.n0 gf180mcu_ocd_ip__classab_buffer_0.se_folded_cascode_np_ab_0.outa1p.n23 3.0083
R1227 gf180mcu_ocd_ip__classab_buffer_0.se_folded_cascode_np_ab_0.outa1p.n1 gf180mcu_ocd_ip__classab_buffer_0.se_folded_cascode_np_ab_0.outa1p.n28 3.00623
R1228 gf180mcu_ocd_ip__classab_buffer_0.se_folded_cascode_np_ab_0.outa1p.n40 gf180mcu_ocd_ip__classab_buffer_0.se_folded_cascode_np_ab_0.outa1p.n11 2.95705
R1229 gf180mcu_ocd_ip__classab_buffer_0.se_folded_cascode_np_ab_0.outa1p.n12 gf180mcu_ocd_ip__classab_buffer_0.se_folded_cascode_np_ab_0.outa1p.n41 2.9183
R1230 gf180mcu_ocd_ip__classab_buffer_0.se_folded_cascode_np_ab_0.outa1p gf180mcu_ocd_ip__classab_buffer_0.se_folded_cascode_np_ab_0.outa1p.n4 2.74465
R1231 gf180mcu_ocd_ip__classab_buffer_0.se_folded_cascode_np_ab_0.outa1p.n36 gf180mcu_ocd_ip__classab_buffer_0.se_folded_cascode_np_ab_0.outa1p.n7 2.71297
R1232 gf180mcu_ocd_ip__classab_buffer_0.se_folded_cascode_np_ab_0.outa1p.n21 gf180mcu_ocd_ip__classab_buffer_0.se_folded_cascode_np_ab_0.outa1p.n7 2.70915
R1233 gf180mcu_ocd_ip__classab_buffer_0.se_folded_cascode_np_ab_0.outa1p.n4 gf180mcu_ocd_ip__classab_buffer_0.se_folded_cascode_np_ab_0.outa1p.n5 2.70654
R1234 gf180mcu_ocd_ip__classab_buffer_0.se_folded_cascode_np_ab_0.outa1p.n40 gf180mcu_ocd_ip__classab_buffer_0.se_folded_cascode_np_ab_0.outa1p.n6 2.70161
R1235 gf180mcu_ocd_ip__classab_buffer_0.se_folded_cascode_np_ab_0.outa1p.n4 gf180mcu_ocd_ip__classab_buffer_0.se_folded_cascode_np_ab_0.outa1p.n41 2.70161
R1236 gf180mcu_ocd_ip__classab_buffer_0.se_folded_cascode_np_ab_0.outa1p.n39 gf180mcu_ocd_ip__classab_buffer_0.se_folded_cascode_np_ab_0.outa1p 2.69799
R1237 gf180mcu_ocd_ip__classab_buffer_0.se_folded_cascode_np_ab_0.outa1p.n37 gf180mcu_ocd_ip__classab_buffer_0.se_folded_cascode_np_ab_0.outa1p 2.69629
R1238 gf180mcu_ocd_ip__classab_buffer_0.se_folded_cascode_np_ab_0.outa1p.n3 gf180mcu_ocd_ip__classab_buffer_0.se_folded_cascode_np_ab_0.outa1p.n27 2.62979
R1239 gf180mcu_ocd_ip__classab_buffer_0.se_folded_cascode_np_ab_0.outa1p.n16 gf180mcu_ocd_ip__classab_buffer_0.se_folded_cascode_np_ab_0.outa1p.n2 2.62979
R1240 gf180mcu_ocd_ip__classab_buffer_0.se_folded_cascode_np_ab_0.outa1p.n24 gf180mcu_ocd_ip__classab_buffer_0.se_folded_cascode_np_ab_0.outa1p.n53 2.42407
R1241 gf180mcu_ocd_ip__classab_buffer_0.se_folded_cascode_np_ab_0.outa1p.n13 gf180mcu_ocd_ip__classab_buffer_0.se_folded_cascode_np_ab_0.outa1p.n14 2.42407
R1242 gf180mcu_ocd_ip__classab_buffer_0.se_folded_cascode_np_ab_0.outa1p gf180mcu_ocd_ip__classab_buffer_0.se_folded_cascode_np_ab_0.outa1p.t30 2.3945
R1243 gf180mcu_ocd_ip__classab_buffer_0.se_folded_cascode_np_ab_0.outa1p gf180mcu_ocd_ip__classab_buffer_0.se_folded_cascode_np_ab_0.outa1p.t26 2.3945
R1244 gf180mcu_ocd_ip__classab_buffer_0.se_folded_cascode_np_ab_0.outa1p gf180mcu_ocd_ip__classab_buffer_0.se_folded_cascode_np_ab_0.outa1p.t25 2.3945
R1245 gf180mcu_ocd_ip__classab_buffer_0.se_folded_cascode_np_ab_0.outa1p gf180mcu_ocd_ip__classab_buffer_0.se_folded_cascode_np_ab_0.outa1p.t24 2.3945
R1246 gf180mcu_ocd_ip__classab_buffer_0.se_folded_cascode_np_ab_0.outa1p gf180mcu_ocd_ip__classab_buffer_0.se_folded_cascode_np_ab_0.outa1p.t23 2.3945
R1247 gf180mcu_ocd_ip__classab_buffer_0.se_folded_cascode_np_ab_0.outa1p gf180mcu_ocd_ip__classab_buffer_0.se_folded_cascode_np_ab_0.outa1p.t29 2.3945
R1248 gf180mcu_ocd_ip__classab_buffer_0.se_folded_cascode_np_ab_0.outa1p gf180mcu_ocd_ip__classab_buffer_0.se_folded_cascode_np_ab_0.outa1p.t28 2.3945
R1249 gf180mcu_ocd_ip__classab_buffer_0.se_folded_cascode_np_ab_0.outa1p gf180mcu_ocd_ip__classab_buffer_0.se_folded_cascode_np_ab_0.outa1p.t27 2.3945
R1250 gf180mcu_ocd_ip__classab_buffer_0.se_folded_cascode_np_ab_0.outa1p.n1 gf180mcu_ocd_ip__classab_buffer_0.se_folded_cascode_np_ab_0.outa1p.n12 2.2505
R1251 gf180mcu_ocd_ip__classab_buffer_0.se_folded_cascode_np_ab_0.outa1p.n46 gf180mcu_ocd_ip__classab_buffer_0.se_folded_cascode_np_ab_0.outa1p.n11 2.2505
R1252 gf180mcu_ocd_ip__classab_buffer_0.se_folded_cascode_np_ab_0.outa1p.n1 gf180mcu_ocd_ip__classab_buffer_0.se_folded_cascode_np_ab_0.outa1p.n0 2.1772
R1253 gf180mcu_ocd_ip__classab_buffer_0.se_folded_cascode_np_ab_0.outa1p.n39 gf180mcu_ocd_ip__classab_buffer_0.se_folded_cascode_np_ab_0.outa1p.n23 2.1605
R1254 gf180mcu_ocd_ip__classab_buffer_0.se_folded_cascode_np_ab_0.outa1p.n38 gf180mcu_ocd_ip__classab_buffer_0.se_folded_cascode_np_ab_0.outa1p.n37 2.1605
R1255 gf180mcu_ocd_ip__classab_buffer_0.se_folded_cascode_np_ab_0.outa1p.n28 gf180mcu_ocd_ip__classab_buffer_0.se_folded_cascode_np_ab_0.outa1p.n5 2.1605
R1256 gf180mcu_ocd_ip__classab_buffer_0.se_folded_cascode_np_ab_0.outa1p.n36 gf180mcu_ocd_ip__classab_buffer_0.se_folded_cascode_np_ab_0.outa1p.n26 2.1605
R1257 gf180mcu_ocd_ip__classab_buffer_0.se_folded_cascode_np_ab_0.outa1p.n35 gf180mcu_ocd_ip__classab_buffer_0.se_folded_cascode_np_ab_0.outa1p.n21 2.1605
R1258 gf180mcu_ocd_ip__classab_buffer_0.se_folded_cascode_np_ab_0.outa1p.n34 gf180mcu_ocd_ip__classab_buffer_0.se_folded_cascode_np_ab_0.outa1p.n33 2.1605
R1259 gf180mcu_ocd_ip__classab_buffer_0.se_folded_cascode_np_ab_0.outa1p.n10 gf180mcu_ocd_ip__classab_buffer_0.se_folded_cascode_np_ab_0.outa1p.n46 1.9304
R1260 gf180mcu_ocd_ip__classab_buffer_0.se_folded_cascode_np_ab_0.outa1p.n9 gf180mcu_ocd_ip__classab_buffer_0.se_folded_cascode_np_ab_0.outa1p.n8 1.82833
R1261 gf180mcu_ocd_ip__classab_buffer_0.se_folded_cascode_np_ab_0.outa1p.n4 gf180mcu_ocd_ip__classab_buffer_0.se_folded_cascode_np_ab_0.outa1p.n6 1.77927
R1262 gf180mcu_ocd_ip__classab_buffer_0.se_folded_cascode_np_ab_0.outa1p.n7 gf180mcu_ocd_ip__classab_buffer_0.se_folded_cascode_np_ab_0.outa1p.n6 1.77588
R1263 gf180mcu_ocd_ip__classab_buffer_0.se_folded_cascode_np_ab_0.outa1p.n46 gf180mcu_ocd_ip__classab_buffer_0.se_folded_cascode_np_ab_0.outa1p.n1 1.68916
R1264 gf180mcu_ocd_ip__classab_buffer_0.se_folded_cascode_np_ab_0.outa1p.n15 gf180mcu_ocd_ip__classab_buffer_0.se_folded_cascode_np_ab_0.outa1p.n52 1.68479
R1265 gf180mcu_ocd_ip__classab_buffer_0.se_folded_cascode_np_ab_0.outa1p.n18 gf180mcu_ocd_ip__classab_buffer_0.se_folded_cascode_np_ab_0.outa1p.n19 1.68479
R1266 gf180mcu_ocd_ip__classab_buffer_0.se_folded_cascode_np_ab_0.outa1p.n20 gf180mcu_ocd_ip__classab_buffer_0.se_folded_cascode_np_ab_0.outa1p.n51 1.68479
R1267 gf180mcu_ocd_ip__classab_buffer_0.se_folded_cascode_np_ab_0.outa1p.n50 gf180mcu_ocd_ip__classab_buffer_0.se_folded_cascode_np_ab_0.outa1p.n22 1.68479
R1268 gf180mcu_ocd_ip__classab_buffer_0.se_folded_cascode_np_ab_0.outa1p.n25 gf180mcu_ocd_ip__classab_buffer_0.se_folded_cascode_np_ab_0.outa1p.n48 1.68479
R1269 gf180mcu_ocd_ip__classab_buffer_0.se_folded_cascode_np_ab_0.outa1p.n49 gf180mcu_ocd_ip__classab_buffer_0.se_folded_cascode_np_ab_0.outa1p.n29 1.68479
R1270 gf180mcu_ocd_ip__classab_buffer_0.se_folded_cascode_np_ab_0.outa1p.n31 gf180mcu_ocd_ip__classab_buffer_0.se_folded_cascode_np_ab_0.outa1p.n30 1.68479
R1271 gf180mcu_ocd_ip__classab_buffer_0.se_folded_cascode_np_ab_0.outa1p.n32 gf180mcu_ocd_ip__classab_buffer_0.se_folded_cascode_np_ab_0.outa1p.n47 1.68479
R1272 gf180mcu_ocd_ip__classab_buffer_0.se_folded_cascode_np_ab_0.outa1p.n32 gf180mcu_ocd_ip__classab_buffer_0.se_folded_cascode_np_ab_0.outa1p.n31 1.68479
R1273 gf180mcu_ocd_ip__classab_buffer_0.se_folded_cascode_np_ab_0.outa1p.n49 gf180mcu_ocd_ip__classab_buffer_0.se_folded_cascode_np_ab_0.outa1p.n30 1.68479
R1274 gf180mcu_ocd_ip__classab_buffer_0.se_folded_cascode_np_ab_0.outa1p.n54 gf180mcu_ocd_ip__classab_buffer_0.se_folded_cascode_np_ab_0.outa1p.n29 1.68479
R1275 gf180mcu_ocd_ip__classab_buffer_0.se_folded_cascode_np_ab_0.outa1p.n48 gf180mcu_ocd_ip__classab_buffer_0.se_folded_cascode_np_ab_0.outa1p.n27 1.68479
R1276 gf180mcu_ocd_ip__classab_buffer_0.se_folded_cascode_np_ab_0.outa1p.n53 gf180mcu_ocd_ip__classab_buffer_0.se_folded_cascode_np_ab_0.outa1p.n25 1.68479
R1277 gf180mcu_ocd_ip__classab_buffer_0.se_folded_cascode_np_ab_0.outa1p.n51 gf180mcu_ocd_ip__classab_buffer_0.se_folded_cascode_np_ab_0.outa1p.n22 1.68479
R1278 gf180mcu_ocd_ip__classab_buffer_0.se_folded_cascode_np_ab_0.outa1p.n20 gf180mcu_ocd_ip__classab_buffer_0.se_folded_cascode_np_ab_0.outa1p.n19 1.68479
R1279 gf180mcu_ocd_ip__classab_buffer_0.se_folded_cascode_np_ab_0.outa1p.n18 gf180mcu_ocd_ip__classab_buffer_0.se_folded_cascode_np_ab_0.outa1p.n17 1.68479
R1280 gf180mcu_ocd_ip__classab_buffer_0.se_folded_cascode_np_ab_0.outa1p.n52 gf180mcu_ocd_ip__classab_buffer_0.se_folded_cascode_np_ab_0.outa1p.n16 1.68479
R1281 gf180mcu_ocd_ip__classab_buffer_0.se_folded_cascode_np_ab_0.outa1p.n15 gf180mcu_ocd_ip__classab_buffer_0.se_folded_cascode_np_ab_0.outa1p.n14 1.68479
R1282 gf180mcu_ocd_ip__classab_buffer_0.se_folded_cascode_np_ab_0.outa1p.n10 gf180mcu_ocd_ip__classab_buffer_0.se_folded_cascode_np_ab_0.outa1p.n9 1.25401
R1283 gf180mcu_ocd_ip__classab_buffer_0.se_folded_cascode_np_ab_0.outa1p.n43 gf180mcu_ocd_ip__classab_buffer_0.se_folded_cascode_np_ab_0.outa1p.n42 1.25073
R1284 gf180mcu_ocd_ip__classab_buffer_0.se_folded_cascode_np_ab_0.outa1p.n45 gf180mcu_ocd_ip__classab_buffer_0.se_folded_cascode_np_ab_0.outa1p.n44 1.24112
R1285 gf180mcu_ocd_ip__classab_buffer_0.se_folded_cascode_np_ab_0.outa1n.n94 gf180mcu_ocd_ip__classab_buffer_0.se_folded_cascode_np_ab_0.outa1n 8.23605
R1286 gf180mcu_ocd_ip__classab_buffer_0.se_folded_cascode_np_ab_0.outa1n.n90 gf180mcu_ocd_ip__classab_buffer_0.se_folded_cascode_np_ab_0.outa1n 8.1864
R1287 gf180mcu_ocd_ip__classab_buffer_0.se_folded_cascode_np_ab_0.outa1n.n47 gf180mcu_ocd_ip__classab_buffer_0.se_folded_cascode_np_ab_0.outa1n.n8 7.17556
R1288 gf180mcu_ocd_ip__classab_buffer_0.se_folded_cascode_np_ab_0.outa1n.n44 gf180mcu_ocd_ip__classab_buffer_0.se_folded_cascode_np_ab_0.outa1n 7.04998
R1289 gf180mcu_ocd_ip__classab_buffer_0.se_folded_cascode_np_ab_0.outa1n.n43 gf180mcu_ocd_ip__classab_buffer_0.se_folded_cascode_np_ab_0.outa1n 7.04998
R1290 gf180mcu_ocd_ip__classab_buffer_0.se_folded_cascode_np_ab_0.outa1n.n42 gf180mcu_ocd_ip__classab_buffer_0.se_folded_cascode_np_ab_0.outa1n 7.04998
R1291 gf180mcu_ocd_ip__classab_buffer_0.se_folded_cascode_np_ab_0.outa1n.n41 gf180mcu_ocd_ip__classab_buffer_0.se_folded_cascode_np_ab_0.outa1n 7.02516
R1292 gf180mcu_ocd_ip__classab_buffer_0.se_folded_cascode_np_ab_0.outa1n.n40 gf180mcu_ocd_ip__classab_buffer_0.se_folded_cascode_np_ab_0.outa1n 7.02516
R1293 gf180mcu_ocd_ip__classab_buffer_0.se_folded_cascode_np_ab_0.outa1n.n38 gf180mcu_ocd_ip__classab_buffer_0.se_folded_cascode_np_ab_0.outa1n 7.02516
R1294 gf180mcu_ocd_ip__classab_buffer_0.se_folded_cascode_np_ab_0.outa1n.n92 gf180mcu_ocd_ip__classab_buffer_0.se_folded_cascode_np_ab_0.outa1n 7.02516
R1295 gf180mcu_ocd_ip__classab_buffer_0.se_folded_cascode_np_ab_0.outa1n.n37 gf180mcu_ocd_ip__classab_buffer_0.se_folded_cascode_np_ab_0.outa1n 7.00033
R1296 gf180mcu_ocd_ip__classab_buffer_0.se_folded_cascode_np_ab_0.outa1n.n10 gf180mcu_ocd_ip__classab_buffer_0.se_folded_cascode_np_ab_0.outa1n 7.00033
R1297 gf180mcu_ocd_ip__classab_buffer_0.se_folded_cascode_np_ab_0.outa1n.n36 gf180mcu_ocd_ip__classab_buffer_0.se_folded_cascode_np_ab_0.outa1n 7.00033
R1298 gf180mcu_ocd_ip__classab_buffer_0.se_folded_cascode_np_ab_0.outa1n.n7 gf180mcu_ocd_ip__classab_buffer_0.se_folded_cascode_np_ab_0.outa1n 6.98308
R1299 gf180mcu_ocd_ip__classab_buffer_0.se_folded_cascode_np_ab_0.outa1n.n35 gf180mcu_ocd_ip__classab_buffer_0.se_folded_cascode_np_ab_0.outa1n 6.98308
R1300 gf180mcu_ocd_ip__classab_buffer_0.se_folded_cascode_np_ab_0.outa1n.n34 gf180mcu_ocd_ip__classab_buffer_0.se_folded_cascode_np_ab_0.outa1n 6.98308
R1301 gf180mcu_ocd_ip__classab_buffer_0.se_folded_cascode_np_ab_0.outa1n.n89 gf180mcu_ocd_ip__classab_buffer_0.se_folded_cascode_np_ab_0.outa1n 6.98308
R1302 gf180mcu_ocd_ip__classab_buffer_0.se_folded_cascode_np_ab_0.outa1n.n9 gf180mcu_ocd_ip__classab_buffer_0.se_folded_cascode_np_ab_0.outa1n.n81 6.18479
R1303 gf180mcu_ocd_ip__classab_buffer_0.se_folded_cascode_np_ab_0.outa1n.n80 gf180mcu_ocd_ip__classab_buffer_0.se_folded_cascode_np_ab_0.outa1n.n8 6.18479
R1304 gf180mcu_ocd_ip__classab_buffer_0.se_folded_cascode_np_ab_0.outa1n.n8 gf180mcu_ocd_ip__classab_buffer_0.se_folded_cascode_np_ab_0.outa1n.n41 5.68657
R1305 gf180mcu_ocd_ip__classab_buffer_0.se_folded_cascode_np_ab_0.outa1n.n9 gf180mcu_ocd_ip__classab_buffer_0.se_folded_cascode_np_ab_0.outa1n.n7 5.68336
R1306 gf180mcu_ocd_ip__classab_buffer_0.se_folded_cascode_np_ab_0.outa1n.n30 gf180mcu_ocd_ip__classab_buffer_0.se_folded_cascode_np_ab_0.outa1n.n55 5.12772
R1307 gf180mcu_ocd_ip__classab_buffer_0.se_folded_cascode_np_ab_0.outa1n.n20 gf180mcu_ocd_ip__classab_buffer_0.se_folded_cascode_np_ab_0.outa1n.n89 5.00193
R1308 gf180mcu_ocd_ip__classab_buffer_0.se_folded_cascode_np_ab_0.outa1n.n92 gf180mcu_ocd_ip__classab_buffer_0.se_folded_cascode_np_ab_0.outa1n.n21 4.99871
R1309 gf180mcu_ocd_ip__classab_buffer_0.se_folded_cascode_np_ab_0.outa1n.n5 gf180mcu_ocd_ip__classab_buffer_0.se_folded_cascode_np_ab_0.outa1n.n71 4.92837
R1310 gf180mcu_ocd_ip__classab_buffer_0.se_folded_cascode_np_ab_0.outa1n.n31 gf180mcu_ocd_ip__classab_buffer_0.se_folded_cascode_np_ab_0.outa1n.n69 4.92837
R1311 gf180mcu_ocd_ip__classab_buffer_0.se_folded_cascode_np_ab_0.outa1n gf180mcu_ocd_ip__classab_buffer_0.se_folded_cascode_np_ab_0.outa1n.n68 4.92837
R1312 gf180mcu_ocd_ip__classab_buffer_0.se_folded_cascode_np_ab_0.outa1n.n30 gf180mcu_ocd_ip__classab_buffer_0.se_folded_cascode_np_ab_0.outa1n.n58 4.92837
R1313 gf180mcu_ocd_ip__classab_buffer_0.se_folded_cascode_np_ab_0.outa1n.n32 gf180mcu_ocd_ip__classab_buffer_0.se_folded_cascode_np_ab_0.outa1n.n61 4.92837
R1314 gf180mcu_ocd_ip__classab_buffer_0.se_folded_cascode_np_ab_0.outa1n.n5 gf180mcu_ocd_ip__classab_buffer_0.se_folded_cascode_np_ab_0.outa1n.n77 4.92837
R1315 gf180mcu_ocd_ip__classab_buffer_0.se_folded_cascode_np_ab_0.outa1n.n5 gf180mcu_ocd_ip__classab_buffer_0.se_folded_cascode_np_ab_0.outa1n.n75 4.92837
R1316 gf180mcu_ocd_ip__classab_buffer_0.se_folded_cascode_np_ab_0.outa1n.n33 gf180mcu_ocd_ip__classab_buffer_0.se_folded_cascode_np_ab_0.outa1n.n63 4.8706
R1317 gf180mcu_ocd_ip__classab_buffer_0.se_folded_cascode_np_ab_0.outa1n.n62 gf180mcu_ocd_ip__classab_buffer_0.se_folded_cascode_np_ab_0.outa1n.t34 4.77176
R1318 gf180mcu_ocd_ip__classab_buffer_0.se_folded_cascode_np_ab_0.outa1n.n53 gf180mcu_ocd_ip__classab_buffer_0.se_folded_cascode_np_ab_0.outa1n.t52 4.77176
R1319 gf180mcu_ocd_ip__classab_buffer_0.se_folded_cascode_np_ab_0.outa1n.n54 gf180mcu_ocd_ip__classab_buffer_0.se_folded_cascode_np_ab_0.outa1n.t53 4.77176
R1320 gf180mcu_ocd_ip__classab_buffer_0.se_folded_cascode_np_ab_0.outa1n.n76 gf180mcu_ocd_ip__classab_buffer_0.se_folded_cascode_np_ab_0.outa1n.t26 4.77176
R1321 gf180mcu_ocd_ip__classab_buffer_0.se_folded_cascode_np_ab_0.outa1n.n70 gf180mcu_ocd_ip__classab_buffer_0.se_folded_cascode_np_ab_0.outa1n.t22 4.77176
R1322 gf180mcu_ocd_ip__classab_buffer_0.se_folded_cascode_np_ab_0.outa1n.n52 gf180mcu_ocd_ip__classab_buffer_0.se_folded_cascode_np_ab_0.outa1n.t20 4.77176
R1323 gf180mcu_ocd_ip__classab_buffer_0.se_folded_cascode_np_ab_0.outa1n.n51 gf180mcu_ocd_ip__classab_buffer_0.se_folded_cascode_np_ab_0.outa1n.t59 4.77176
R1324 gf180mcu_ocd_ip__classab_buffer_0.se_folded_cascode_np_ab_0.outa1n.n74 gf180mcu_ocd_ip__classab_buffer_0.se_folded_cascode_np_ab_0.outa1n.t24 4.77176
R1325 gf180mcu_ocd_ip__classab_buffer_0.se_folded_cascode_np_ab_0.outa1n.n71 gf180mcu_ocd_ip__classab_buffer_0.se_folded_cascode_np_ab_0.outa1n.t56 4.77176
R1326 gf180mcu_ocd_ip__classab_buffer_0.se_folded_cascode_np_ab_0.outa1n.n69 gf180mcu_ocd_ip__classab_buffer_0.se_folded_cascode_np_ab_0.outa1n.t57 4.77176
R1327 gf180mcu_ocd_ip__classab_buffer_0.se_folded_cascode_np_ab_0.outa1n.n68 gf180mcu_ocd_ip__classab_buffer_0.se_folded_cascode_np_ab_0.outa1n.t58 4.77176
R1328 gf180mcu_ocd_ip__classab_buffer_0.se_folded_cascode_np_ab_0.outa1n.n49 gf180mcu_ocd_ip__classab_buffer_0.se_folded_cascode_np_ab_0.outa1n.t18 4.77176
R1329 gf180mcu_ocd_ip__classab_buffer_0.se_folded_cascode_np_ab_0.outa1n.n48 gf180mcu_ocd_ip__classab_buffer_0.se_folded_cascode_np_ab_0.outa1n.t16 4.77176
R1330 gf180mcu_ocd_ip__classab_buffer_0.se_folded_cascode_np_ab_0.outa1n.n55 gf180mcu_ocd_ip__classab_buffer_0.se_folded_cascode_np_ab_0.outa1n.t48 4.77176
R1331 gf180mcu_ocd_ip__classab_buffer_0.se_folded_cascode_np_ab_0.outa1n.n56 gf180mcu_ocd_ip__classab_buffer_0.se_folded_cascode_np_ab_0.outa1n.t38 4.77176
R1332 gf180mcu_ocd_ip__classab_buffer_0.se_folded_cascode_np_ab_0.outa1n.n58 gf180mcu_ocd_ip__classab_buffer_0.se_folded_cascode_np_ab_0.outa1n.t49 4.77176
R1333 gf180mcu_ocd_ip__classab_buffer_0.se_folded_cascode_np_ab_0.outa1n.n59 gf180mcu_ocd_ip__classab_buffer_0.se_folded_cascode_np_ab_0.outa1n.t36 4.77176
R1334 gf180mcu_ocd_ip__classab_buffer_0.se_folded_cascode_np_ab_0.outa1n.n61 gf180mcu_ocd_ip__classab_buffer_0.se_folded_cascode_np_ab_0.outa1n.t50 4.77176
R1335 gf180mcu_ocd_ip__classab_buffer_0.se_folded_cascode_np_ab_0.outa1n.n63 gf180mcu_ocd_ip__classab_buffer_0.se_folded_cascode_np_ab_0.outa1n.t51 4.77176
R1336 gf180mcu_ocd_ip__classab_buffer_0.se_folded_cascode_np_ab_0.outa1n.n64 gf180mcu_ocd_ip__classab_buffer_0.se_folded_cascode_np_ab_0.outa1n.t32 4.77176
R1337 gf180mcu_ocd_ip__classab_buffer_0.se_folded_cascode_np_ab_0.outa1n.n66 gf180mcu_ocd_ip__classab_buffer_0.se_folded_cascode_np_ab_0.outa1n.t30 4.77176
R1338 gf180mcu_ocd_ip__classab_buffer_0.se_folded_cascode_np_ab_0.outa1n.n78 gf180mcu_ocd_ip__classab_buffer_0.se_folded_cascode_np_ab_0.outa1n.t28 4.77176
R1339 gf180mcu_ocd_ip__classab_buffer_0.se_folded_cascode_np_ab_0.outa1n.n77 gf180mcu_ocd_ip__classab_buffer_0.se_folded_cascode_np_ab_0.outa1n.t54 4.77176
R1340 gf180mcu_ocd_ip__classab_buffer_0.se_folded_cascode_np_ab_0.outa1n.n75 gf180mcu_ocd_ip__classab_buffer_0.se_folded_cascode_np_ab_0.outa1n.t55 4.77176
R1341 gf180mcu_ocd_ip__classab_buffer_0.se_folded_cascode_np_ab_0.outa1n.n29 gf180mcu_ocd_ip__classab_buffer_0.se_folded_cascode_np_ab_0.outa1n.n43 4.5005
R1342 gf180mcu_ocd_ip__classab_buffer_0.se_folded_cascode_np_ab_0.outa1n.n11 gf180mcu_ocd_ip__classab_buffer_0.se_folded_cascode_np_ab_0.outa1n.n72 4.5005
R1343 gf180mcu_ocd_ip__classab_buffer_0.se_folded_cascode_np_ab_0.outa1n.n11 gf180mcu_ocd_ip__classab_buffer_0.se_folded_cascode_np_ab_0.outa1n.n10 4.5005
R1344 gf180mcu_ocd_ip__classab_buffer_0.se_folded_cascode_np_ab_0.outa1n.n87 gf180mcu_ocd_ip__classab_buffer_0.se_folded_cascode_np_ab_0.outa1n.n86 4.5005
R1345 gf180mcu_ocd_ip__classab_buffer_0.se_folded_cascode_np_ab_0.outa1n.n88 gf180mcu_ocd_ip__classab_buffer_0.se_folded_cascode_np_ab_0.outa1n.n19 4.5005
R1346 gf180mcu_ocd_ip__classab_buffer_0.se_folded_cascode_np_ab_0.outa1n.n34 gf180mcu_ocd_ip__classab_buffer_0.se_folded_cascode_np_ab_0.outa1n.n0 4.5005
R1347 gf180mcu_ocd_ip__classab_buffer_0.se_folded_cascode_np_ab_0.outa1n.n35 gf180mcu_ocd_ip__classab_buffer_0.se_folded_cascode_np_ab_0.outa1n.n85 4.5005
R1348 gf180mcu_ocd_ip__classab_buffer_0.se_folded_cascode_np_ab_0.outa1n.n14 gf180mcu_ocd_ip__classab_buffer_0.se_folded_cascode_np_ab_0.outa1n.n83 4.5005
R1349 gf180mcu_ocd_ip__classab_buffer_0.se_folded_cascode_np_ab_0.outa1n.n7 gf180mcu_ocd_ip__classab_buffer_0.se_folded_cascode_np_ab_0.outa1n.n82 4.5005
R1350 gf180mcu_ocd_ip__classab_buffer_0.se_folded_cascode_np_ab_0.outa1n.n12 gf180mcu_ocd_ip__classab_buffer_0.se_folded_cascode_np_ab_0.outa1n.n80 4.5005
R1351 gf180mcu_ocd_ip__classab_buffer_0.se_folded_cascode_np_ab_0.outa1n.n41 gf180mcu_ocd_ip__classab_buffer_0.se_folded_cascode_np_ab_0.outa1n.n13 4.5005
R1352 gf180mcu_ocd_ip__classab_buffer_0.se_folded_cascode_np_ab_0.outa1n.n81 gf180mcu_ocd_ip__classab_buffer_0.se_folded_cascode_np_ab_0.outa1n.n13 4.5005
R1353 gf180mcu_ocd_ip__classab_buffer_0.se_folded_cascode_np_ab_0.outa1n.n90 gf180mcu_ocd_ip__classab_buffer_0.se_folded_cascode_np_ab_0.outa1n.n21 4.5005
R1354 gf180mcu_ocd_ip__classab_buffer_0.se_folded_cascode_np_ab_0.outa1n.n36 gf180mcu_ocd_ip__classab_buffer_0.se_folded_cascode_np_ab_0.outa1n.n19 4.5005
R1355 gf180mcu_ocd_ip__classab_buffer_0.se_folded_cascode_np_ab_0.outa1n.n18 gf180mcu_ocd_ip__classab_buffer_0.se_folded_cascode_np_ab_0.outa1n.n91 4.5005
R1356 gf180mcu_ocd_ip__classab_buffer_0.se_folded_cascode_np_ab_0.outa1n.n16 gf180mcu_ocd_ip__classab_buffer_0.se_folded_cascode_np_ab_0.outa1n.n84 4.5005
R1357 gf180mcu_ocd_ip__classab_buffer_0.se_folded_cascode_np_ab_0.outa1n.n37 gf180mcu_ocd_ip__classab_buffer_0.se_folded_cascode_np_ab_0.outa1n.n15 4.5005
R1358 gf180mcu_ocd_ip__classab_buffer_0.se_folded_cascode_np_ab_0.outa1n.n44 gf180mcu_ocd_ip__classab_buffer_0.se_folded_cascode_np_ab_0.outa1n.n28 4.5005
R1359 gf180mcu_ocd_ip__classab_buffer_0.se_folded_cascode_np_ab_0.outa1n.n39 gf180mcu_ocd_ip__classab_buffer_0.se_folded_cascode_np_ab_0.outa1n.n15 4.5005
R1360 gf180mcu_ocd_ip__classab_buffer_0.se_folded_cascode_np_ab_0.outa1n.n6 gf180mcu_ocd_ip__classab_buffer_0.se_folded_cascode_np_ab_0.outa1n.n93 4.5005
R1361 gf180mcu_ocd_ip__classab_buffer_0.se_folded_cascode_np_ab_0.outa1n.n38 gf180mcu_ocd_ip__classab_buffer_0.se_folded_cascode_np_ab_0.outa1n.n18 4.5005
R1362 gf180mcu_ocd_ip__classab_buffer_0.se_folded_cascode_np_ab_0.outa1n.n40 gf180mcu_ocd_ip__classab_buffer_0.se_folded_cascode_np_ab_0.outa1n.n16 4.5005
R1363 gf180mcu_ocd_ip__classab_buffer_0.se_folded_cascode_np_ab_0.outa1n.n23 gf180mcu_ocd_ip__classab_buffer_0.se_folded_cascode_np_ab_0.outa1n.n22 4.5005
R1364 gf180mcu_ocd_ip__classab_buffer_0.se_folded_cascode_np_ab_0.outa1n.n27 gf180mcu_ocd_ip__classab_buffer_0.se_folded_cascode_np_ab_0.outa1n.n94 4.5005
R1365 gf180mcu_ocd_ip__classab_buffer_0.se_folded_cascode_np_ab_0.outa1n.n42 gf180mcu_ocd_ip__classab_buffer_0.se_folded_cascode_np_ab_0.outa1n.n6 4.5005
R1366 gf180mcu_ocd_ip__classab_buffer_0.se_folded_cascode_np_ab_0.outa1n.n73 gf180mcu_ocd_ip__classab_buffer_0.se_folded_cascode_np_ab_0.outa1n.n17 4.5005
R1367 gf180mcu_ocd_ip__classab_buffer_0.se_folded_cascode_np_ab_0.outa1n.n24 gf180mcu_ocd_ip__classab_buffer_0.se_folded_cascode_np_ab_0.outa1n 4.46443
R1368 gf180mcu_ocd_ip__classab_buffer_0.se_folded_cascode_np_ab_0.outa1n.n26 gf180mcu_ocd_ip__classab_buffer_0.se_folded_cascode_np_ab_0.outa1n 4.45145
R1369 gf180mcu_ocd_ip__classab_buffer_0.se_folded_cascode_np_ab_0.outa1n gf180mcu_ocd_ip__classab_buffer_0.se_folded_cascode_np_ab_0.outa1n.t35 4.4205
R1370 gf180mcu_ocd_ip__classab_buffer_0.se_folded_cascode_np_ab_0.outa1n gf180mcu_ocd_ip__classab_buffer_0.se_folded_cascode_np_ab_0.outa1n.t15 4.4205
R1371 gf180mcu_ocd_ip__classab_buffer_0.se_folded_cascode_np_ab_0.outa1n gf180mcu_ocd_ip__classab_buffer_0.se_folded_cascode_np_ab_0.outa1n.t14 4.4205
R1372 gf180mcu_ocd_ip__classab_buffer_0.se_folded_cascode_np_ab_0.outa1n gf180mcu_ocd_ip__classab_buffer_0.se_folded_cascode_np_ab_0.outa1n.t13 4.4205
R1373 gf180mcu_ocd_ip__classab_buffer_0.se_folded_cascode_np_ab_0.outa1n gf180mcu_ocd_ip__classab_buffer_0.se_folded_cascode_np_ab_0.outa1n.t12 4.4205
R1374 gf180mcu_ocd_ip__classab_buffer_0.se_folded_cascode_np_ab_0.outa1n gf180mcu_ocd_ip__classab_buffer_0.se_folded_cascode_np_ab_0.outa1n.t11 4.4205
R1375 gf180mcu_ocd_ip__classab_buffer_0.se_folded_cascode_np_ab_0.outa1n gf180mcu_ocd_ip__classab_buffer_0.se_folded_cascode_np_ab_0.outa1n.t10 4.4205
R1376 gf180mcu_ocd_ip__classab_buffer_0.se_folded_cascode_np_ab_0.outa1n gf180mcu_ocd_ip__classab_buffer_0.se_folded_cascode_np_ab_0.outa1n.t9 4.4205
R1377 gf180mcu_ocd_ip__classab_buffer_0.se_folded_cascode_np_ab_0.outa1n gf180mcu_ocd_ip__classab_buffer_0.se_folded_cascode_np_ab_0.outa1n.t8 4.4205
R1378 gf180mcu_ocd_ip__classab_buffer_0.se_folded_cascode_np_ab_0.outa1n gf180mcu_ocd_ip__classab_buffer_0.se_folded_cascode_np_ab_0.outa1n.t7 4.4205
R1379 gf180mcu_ocd_ip__classab_buffer_0.se_folded_cascode_np_ab_0.outa1n gf180mcu_ocd_ip__classab_buffer_0.se_folded_cascode_np_ab_0.outa1n.t6 4.4205
R1380 gf180mcu_ocd_ip__classab_buffer_0.se_folded_cascode_np_ab_0.outa1n gf180mcu_ocd_ip__classab_buffer_0.se_folded_cascode_np_ab_0.outa1n.t5 4.4205
R1381 gf180mcu_ocd_ip__classab_buffer_0.se_folded_cascode_np_ab_0.outa1n gf180mcu_ocd_ip__classab_buffer_0.se_folded_cascode_np_ab_0.outa1n.t4 4.4205
R1382 gf180mcu_ocd_ip__classab_buffer_0.se_folded_cascode_np_ab_0.outa1n gf180mcu_ocd_ip__classab_buffer_0.se_folded_cascode_np_ab_0.outa1n.t27 4.4205
R1383 gf180mcu_ocd_ip__classab_buffer_0.se_folded_cascode_np_ab_0.outa1n gf180mcu_ocd_ip__classab_buffer_0.se_folded_cascode_np_ab_0.outa1n.t3 4.4205
R1384 gf180mcu_ocd_ip__classab_buffer_0.se_folded_cascode_np_ab_0.outa1n gf180mcu_ocd_ip__classab_buffer_0.se_folded_cascode_np_ab_0.outa1n.t2 4.4205
R1385 gf180mcu_ocd_ip__classab_buffer_0.se_folded_cascode_np_ab_0.outa1n gf180mcu_ocd_ip__classab_buffer_0.se_folded_cascode_np_ab_0.outa1n.t1 4.4205
R1386 gf180mcu_ocd_ip__classab_buffer_0.se_folded_cascode_np_ab_0.outa1n gf180mcu_ocd_ip__classab_buffer_0.se_folded_cascode_np_ab_0.outa1n.t0 4.4205
R1387 gf180mcu_ocd_ip__classab_buffer_0.se_folded_cascode_np_ab_0.outa1n gf180mcu_ocd_ip__classab_buffer_0.se_folded_cascode_np_ab_0.outa1n.t23 4.4205
R1388 gf180mcu_ocd_ip__classab_buffer_0.se_folded_cascode_np_ab_0.outa1n gf180mcu_ocd_ip__classab_buffer_0.se_folded_cascode_np_ab_0.outa1n.t21 4.4205
R1389 gf180mcu_ocd_ip__classab_buffer_0.se_folded_cascode_np_ab_0.outa1n gf180mcu_ocd_ip__classab_buffer_0.se_folded_cascode_np_ab_0.outa1n.t25 4.4205
R1390 gf180mcu_ocd_ip__classab_buffer_0.se_folded_cascode_np_ab_0.outa1n gf180mcu_ocd_ip__classab_buffer_0.se_folded_cascode_np_ab_0.outa1n.t19 4.4205
R1391 gf180mcu_ocd_ip__classab_buffer_0.se_folded_cascode_np_ab_0.outa1n gf180mcu_ocd_ip__classab_buffer_0.se_folded_cascode_np_ab_0.outa1n.t17 4.4205
R1392 gf180mcu_ocd_ip__classab_buffer_0.se_folded_cascode_np_ab_0.outa1n gf180mcu_ocd_ip__classab_buffer_0.se_folded_cascode_np_ab_0.outa1n.t39 4.4205
R1393 gf180mcu_ocd_ip__classab_buffer_0.se_folded_cascode_np_ab_0.outa1n gf180mcu_ocd_ip__classab_buffer_0.se_folded_cascode_np_ab_0.outa1n.t37 4.4205
R1394 gf180mcu_ocd_ip__classab_buffer_0.se_folded_cascode_np_ab_0.outa1n gf180mcu_ocd_ip__classab_buffer_0.se_folded_cascode_np_ab_0.outa1n.t33 4.4205
R1395 gf180mcu_ocd_ip__classab_buffer_0.se_folded_cascode_np_ab_0.outa1n gf180mcu_ocd_ip__classab_buffer_0.se_folded_cascode_np_ab_0.outa1n.t31 4.4205
R1396 gf180mcu_ocd_ip__classab_buffer_0.se_folded_cascode_np_ab_0.outa1n gf180mcu_ocd_ip__classab_buffer_0.se_folded_cascode_np_ab_0.outa1n.t29 4.4205
R1397 gf180mcu_ocd_ip__classab_buffer_0.se_folded_cascode_np_ab_0.outa1n.n4 gf180mcu_ocd_ip__classab_buffer_0.se_folded_cascode_np_ab_0.outa1n.n9 3.8759
R1398 gf180mcu_ocd_ip__classab_buffer_0.se_folded_cascode_np_ab_0.outa1n gf180mcu_ocd_ip__classab_buffer_0.se_folded_cascode_np_ab_0.outa1n.n25 3.83932
R1399 gf180mcu_ocd_ip__classab_buffer_0.se_folded_cascode_np_ab_0.outa1n.n25 gf180mcu_ocd_ip__classab_buffer_0.se_folded_cascode_np_ab_0.outa1n 3.83932
R1400 gf180mcu_ocd_ip__classab_buffer_0.se_folded_cascode_np_ab_0.outa1n.n24 gf180mcu_ocd_ip__classab_buffer_0.se_folded_cascode_np_ab_0.outa1n 3.83932
R1401 gf180mcu_ocd_ip__classab_buffer_0.se_folded_cascode_np_ab_0.outa1n.n26 gf180mcu_ocd_ip__classab_buffer_0.se_folded_cascode_np_ab_0.outa1n 3.83932
R1402 gf180mcu_ocd_ip__classab_buffer_0.se_folded_cascode_np_ab_0.outa1n.n95 gf180mcu_ocd_ip__classab_buffer_0.se_folded_cascode_np_ab_0.outa1n 3.83813
R1403 gf180mcu_ocd_ip__classab_buffer_0.se_folded_cascode_np_ab_0.outa1n.n26 gf180mcu_ocd_ip__classab_buffer_0.se_folded_cascode_np_ab_0.outa1n 3.83813
R1404 gf180mcu_ocd_ip__classab_buffer_0.se_folded_cascode_np_ab_0.outa1n.n2 gf180mcu_ocd_ip__classab_buffer_0.se_folded_cascode_np_ab_0.outa1n.n46 3.62835
R1405 gf180mcu_ocd_ip__classab_buffer_0.se_folded_cascode_np_ab_0.outa1n.n25 gf180mcu_ocd_ip__classab_buffer_0.se_folded_cascode_np_ab_0.outa1n 3.44401
R1406 gf180mcu_ocd_ip__classab_buffer_0.se_folded_cascode_np_ab_0.outa1n gf180mcu_ocd_ip__classab_buffer_0.se_folded_cascode_np_ab_0.outa1n.n95 3.10314
R1407 gf180mcu_ocd_ip__classab_buffer_0.se_folded_cascode_np_ab_0.outa1n.n19 gf180mcu_ocd_ip__classab_buffer_0.se_folded_cascode_np_ab_0.outa1n.n3 3.04138
R1408 gf180mcu_ocd_ip__classab_buffer_0.se_folded_cascode_np_ab_0.outa1n.n82 gf180mcu_ocd_ip__classab_buffer_0.se_folded_cascode_np_ab_0.outa1n.n4 2.9819
R1409 gf180mcu_ocd_ip__classab_buffer_0.se_folded_cascode_np_ab_0.outa1n.n20 gf180mcu_ocd_ip__classab_buffer_0.se_folded_cascode_np_ab_0.outa1n.n2 2.98018
R1410 gf180mcu_ocd_ip__classab_buffer_0.se_folded_cascode_np_ab_0.outa1n.n14 gf180mcu_ocd_ip__classab_buffer_0.se_folded_cascode_np_ab_0.outa1n.n4 2.97686
R1411 gf180mcu_ocd_ip__classab_buffer_0.se_folded_cascode_np_ab_0.outa1n.n85 gf180mcu_ocd_ip__classab_buffer_0.se_folded_cascode_np_ab_0.outa1n.n1 2.97686
R1412 gf180mcu_ocd_ip__classab_buffer_0.se_folded_cascode_np_ab_0.outa1n.n3 gf180mcu_ocd_ip__classab_buffer_0.se_folded_cascode_np_ab_0.outa1n.n0 2.97664
R1413 gf180mcu_ocd_ip__classab_buffer_0.se_folded_cascode_np_ab_0.outa1n.n1 gf180mcu_ocd_ip__classab_buffer_0.se_folded_cascode_np_ab_0.outa1n.n87 2.97032
R1414 gf180mcu_ocd_ip__classab_buffer_0.se_folded_cascode_np_ab_0.outa1n.n6 gf180mcu_ocd_ip__classab_buffer_0.se_folded_cascode_np_ab_0.outa1n.n19 2.93922
R1415 gf180mcu_ocd_ip__classab_buffer_0.se_folded_cascode_np_ab_0.outa1n.n50 gf180mcu_ocd_ip__classab_buffer_0.se_folded_cascode_np_ab_0.outa1n 2.81271
R1416 gf180mcu_ocd_ip__classab_buffer_0.se_folded_cascode_np_ab_0.outa1n.n6 gf180mcu_ocd_ip__classab_buffer_0.se_folded_cascode_np_ab_0.outa1n 2.80488
R1417 gf180mcu_ocd_ip__classab_buffer_0.se_folded_cascode_np_ab_0.outa1n.n46 gf180mcu_ocd_ip__classab_buffer_0.se_folded_cascode_np_ab_0.outa1n 2.80014
R1418 gf180mcu_ocd_ip__classab_buffer_0.se_folded_cascode_np_ab_0.outa1n.n47 gf180mcu_ocd_ip__classab_buffer_0.se_folded_cascode_np_ab_0.outa1n 2.79857
R1419 gf180mcu_ocd_ip__classab_buffer_0.se_folded_cascode_np_ab_0.outa1n.n65 gf180mcu_ocd_ip__classab_buffer_0.se_folded_cascode_np_ab_0.outa1n 2.78052
R1420 gf180mcu_ocd_ip__classab_buffer_0.se_folded_cascode_np_ab_0.outa1n.n79 gf180mcu_ocd_ip__classab_buffer_0.se_folded_cascode_np_ab_0.outa1n 2.77849
R1421 gf180mcu_ocd_ip__classab_buffer_0.se_folded_cascode_np_ab_0.outa1n.n67 gf180mcu_ocd_ip__classab_buffer_0.se_folded_cascode_np_ab_0.outa1n 2.7773
R1422 gf180mcu_ocd_ip__classab_buffer_0.se_folded_cascode_np_ab_0.outa1n.n29 gf180mcu_ocd_ip__classab_buffer_0.se_folded_cascode_np_ab_0.outa1n 2.77571
R1423 gf180mcu_ocd_ip__classab_buffer_0.se_folded_cascode_np_ab_0.outa1n.n17 gf180mcu_ocd_ip__classab_buffer_0.se_folded_cascode_np_ab_0.outa1n 2.77333
R1424 gf180mcu_ocd_ip__classab_buffer_0.se_folded_cascode_np_ab_0.outa1n.n60 gf180mcu_ocd_ip__classab_buffer_0.se_folded_cascode_np_ab_0.outa1n 2.7724
R1425 gf180mcu_ocd_ip__classab_buffer_0.se_folded_cascode_np_ab_0.outa1n.n57 gf180mcu_ocd_ip__classab_buffer_0.se_folded_cascode_np_ab_0.outa1n 2.75878
R1426 gf180mcu_ocd_ip__classab_buffer_0.se_folded_cascode_np_ab_0.outa1n.n57 gf180mcu_ocd_ip__classab_buffer_0.se_folded_cascode_np_ab_0.outa1n.n56 2.69165
R1427 gf180mcu_ocd_ip__classab_buffer_0.se_folded_cascode_np_ab_0.outa1n.n28 gf180mcu_ocd_ip__classab_buffer_0.se_folded_cascode_np_ab_0.outa1n.n54 2.67837
R1428 gf180mcu_ocd_ip__classab_buffer_0.se_folded_cascode_np_ab_0.outa1n.n65 gf180mcu_ocd_ip__classab_buffer_0.se_folded_cascode_np_ab_0.outa1n.n64 2.67312
R1429 gf180mcu_ocd_ip__classab_buffer_0.se_folded_cascode_np_ab_0.outa1n.n67 gf180mcu_ocd_ip__classab_buffer_0.se_folded_cascode_np_ab_0.outa1n.n66 2.66991
R1430 gf180mcu_ocd_ip__classab_buffer_0.se_folded_cascode_np_ab_0.outa1n.n79 gf180mcu_ocd_ip__classab_buffer_0.se_folded_cascode_np_ab_0.outa1n.n78 2.66872
R1431 gf180mcu_ocd_ip__classab_buffer_0.se_folded_cascode_np_ab_0.outa1n.n50 gf180mcu_ocd_ip__classab_buffer_0.se_folded_cascode_np_ab_0.outa1n.n49 2.6594
R1432 gf180mcu_ocd_ip__classab_buffer_0.se_folded_cascode_np_ab_0.outa1n.n29 gf180mcu_ocd_ip__classab_buffer_0.se_folded_cascode_np_ab_0.outa1n.n74 2.65809
R1433 gf180mcu_ocd_ip__classab_buffer_0.se_folded_cascode_np_ab_0.outa1n.n23 gf180mcu_ocd_ip__classab_buffer_0.se_folded_cascode_np_ab_0.outa1n 2.65457
R1434 gf180mcu_ocd_ip__classab_buffer_0.se_folded_cascode_np_ab_0.outa1n.n23 gf180mcu_ocd_ip__classab_buffer_0.se_folded_cascode_np_ab_0.outa1n.n76 2.63209
R1435 gf180mcu_ocd_ip__classab_buffer_0.se_folded_cascode_np_ab_0.outa1n.n12 gf180mcu_ocd_ip__classab_buffer_0.se_folded_cascode_np_ab_0.outa1n.n53 2.61837
R1436 gf180mcu_ocd_ip__classab_buffer_0.se_folded_cascode_np_ab_0.outa1n.n27 gf180mcu_ocd_ip__classab_buffer_0.se_folded_cascode_np_ab_0.outa1n.n51 2.61072
R1437 gf180mcu_ocd_ip__classab_buffer_0.se_folded_cascode_np_ab_0.outa1n.n60 gf180mcu_ocd_ip__classab_buffer_0.se_folded_cascode_np_ab_0.outa1n.n59 2.59405
R1438 gf180mcu_ocd_ip__classab_buffer_0.se_folded_cascode_np_ab_0.outa1n.n46 gf180mcu_ocd_ip__classab_buffer_0.se_folded_cascode_np_ab_0.outa1n.n48 2.57728
R1439 gf180mcu_ocd_ip__classab_buffer_0.se_folded_cascode_np_ab_0.outa1n.n6 gf180mcu_ocd_ip__classab_buffer_0.se_folded_cascode_np_ab_0.outa1n.n52 2.57407
R1440 gf180mcu_ocd_ip__classab_buffer_0.se_folded_cascode_np_ab_0.outa1n.n47 gf180mcu_ocd_ip__classab_buffer_0.se_folded_cascode_np_ab_0.outa1n.n62 2.57086
R1441 gf180mcu_ocd_ip__classab_buffer_0.se_folded_cascode_np_ab_0.outa1n.n17 gf180mcu_ocd_ip__classab_buffer_0.se_folded_cascode_np_ab_0.outa1n.n70 2.57086
R1442 gf180mcu_ocd_ip__classab_buffer_0.se_folded_cascode_np_ab_0.outa1n gf180mcu_ocd_ip__classab_buffer_0.se_folded_cascode_np_ab_0.outa1n.t47 2.3945
R1443 gf180mcu_ocd_ip__classab_buffer_0.se_folded_cascode_np_ab_0.outa1n gf180mcu_ocd_ip__classab_buffer_0.se_folded_cascode_np_ab_0.outa1n.t46 2.3945
R1444 gf180mcu_ocd_ip__classab_buffer_0.se_folded_cascode_np_ab_0.outa1n gf180mcu_ocd_ip__classab_buffer_0.se_folded_cascode_np_ab_0.outa1n.t45 2.3945
R1445 gf180mcu_ocd_ip__classab_buffer_0.se_folded_cascode_np_ab_0.outa1n gf180mcu_ocd_ip__classab_buffer_0.se_folded_cascode_np_ab_0.outa1n.t44 2.3945
R1446 gf180mcu_ocd_ip__classab_buffer_0.se_folded_cascode_np_ab_0.outa1n gf180mcu_ocd_ip__classab_buffer_0.se_folded_cascode_np_ab_0.outa1n.t43 2.3945
R1447 gf180mcu_ocd_ip__classab_buffer_0.se_folded_cascode_np_ab_0.outa1n gf180mcu_ocd_ip__classab_buffer_0.se_folded_cascode_np_ab_0.outa1n.t42 2.3945
R1448 gf180mcu_ocd_ip__classab_buffer_0.se_folded_cascode_np_ab_0.outa1n gf180mcu_ocd_ip__classab_buffer_0.se_folded_cascode_np_ab_0.outa1n.t41 2.3945
R1449 gf180mcu_ocd_ip__classab_buffer_0.se_folded_cascode_np_ab_0.outa1n gf180mcu_ocd_ip__classab_buffer_0.se_folded_cascode_np_ab_0.outa1n.t40 2.3945
R1450 gf180mcu_ocd_ip__classab_buffer_0.se_folded_cascode_np_ab_0.outa1n.n46 gf180mcu_ocd_ip__classab_buffer_0.se_folded_cascode_np_ab_0.outa1n 2.39178
R1451 gf180mcu_ocd_ip__classab_buffer_0.se_folded_cascode_np_ab_0.outa1n.n32 gf180mcu_ocd_ip__classab_buffer_0.se_folded_cascode_np_ab_0.outa1n.n47 2.25239
R1452 gf180mcu_ocd_ip__classab_buffer_0.se_folded_cascode_np_ab_0.outa1n.n5 gf180mcu_ocd_ip__classab_buffer_0.se_folded_cascode_np_ab_0.outa1n.n23 2.2505
R1453 gf180mcu_ocd_ip__classab_buffer_0.se_folded_cascode_np_ab_0.outa1n.n45 gf180mcu_ocd_ip__classab_buffer_0.se_folded_cascode_np_ab_0.outa1n.n79 2.2505
R1454 gf180mcu_ocd_ip__classab_buffer_0.se_folded_cascode_np_ab_0.outa1n.n28 gf180mcu_ocd_ip__classab_buffer_0.se_folded_cascode_np_ab_0.outa1n.n45 2.2505
R1455 gf180mcu_ocd_ip__classab_buffer_0.se_folded_cascode_np_ab_0.outa1n.n33 gf180mcu_ocd_ip__classab_buffer_0.se_folded_cascode_np_ab_0.outa1n.n67 2.2505
R1456 gf180mcu_ocd_ip__classab_buffer_0.se_folded_cascode_np_ab_0.outa1n.n33 gf180mcu_ocd_ip__classab_buffer_0.se_folded_cascode_np_ab_0.outa1n.n12 2.2505
R1457 gf180mcu_ocd_ip__classab_buffer_0.se_folded_cascode_np_ab_0.outa1n.n33 gf180mcu_ocd_ip__classab_buffer_0.se_folded_cascode_np_ab_0.outa1n.n65 2.2505
R1458 gf180mcu_ocd_ip__classab_buffer_0.se_folded_cascode_np_ab_0.outa1n.n30 gf180mcu_ocd_ip__classab_buffer_0.se_folded_cascode_np_ab_0.outa1n.n60 2.2505
R1459 gf180mcu_ocd_ip__classab_buffer_0.se_folded_cascode_np_ab_0.outa1n.n30 gf180mcu_ocd_ip__classab_buffer_0.se_folded_cascode_np_ab_0.outa1n.n57 2.2505
R1460 gf180mcu_ocd_ip__classab_buffer_0.se_folded_cascode_np_ab_0.outa1n gf180mcu_ocd_ip__classab_buffer_0.se_folded_cascode_np_ab_0.outa1n.n27 2.2505
R1461 gf180mcu_ocd_ip__classab_buffer_0.se_folded_cascode_np_ab_0.outa1n gf180mcu_ocd_ip__classab_buffer_0.se_folded_cascode_np_ab_0.outa1n.n50 2.2505
R1462 gf180mcu_ocd_ip__classab_buffer_0.se_folded_cascode_np_ab_0.outa1n.n31 gf180mcu_ocd_ip__classab_buffer_0.se_folded_cascode_np_ab_0.outa1n.n6 2.2505
R1463 gf180mcu_ocd_ip__classab_buffer_0.se_folded_cascode_np_ab_0.outa1n.n5 gf180mcu_ocd_ip__classab_buffer_0.se_folded_cascode_np_ab_0.outa1n.n17 2.2505
R1464 gf180mcu_ocd_ip__classab_buffer_0.se_folded_cascode_np_ab_0.outa1n.n5 gf180mcu_ocd_ip__classab_buffer_0.se_folded_cascode_np_ab_0.outa1n.n29 2.2505
R1465 gf180mcu_ocd_ip__classab_buffer_0.se_folded_cascode_np_ab_0.outa1n.n83 gf180mcu_ocd_ip__classab_buffer_0.se_folded_cascode_np_ab_0.outa1n.n7 2.18621
R1466 gf180mcu_ocd_ip__classab_buffer_0.se_folded_cascode_np_ab_0.outa1n.n41 gf180mcu_ocd_ip__classab_buffer_0.se_folded_cascode_np_ab_0.outa1n.n39 2.183
R1467 gf180mcu_ocd_ip__classab_buffer_0.se_folded_cascode_np_ab_0.outa1n.n9 gf180mcu_ocd_ip__classab_buffer_0.se_folded_cascode_np_ab_0.outa1n.n8 2.1605
R1468 gf180mcu_ocd_ip__classab_buffer_0.se_folded_cascode_np_ab_0.outa1n.n45 gf180mcu_ocd_ip__classab_buffer_0.se_folded_cascode_np_ab_0.outa1n.n5 1.9574
R1469 gf180mcu_ocd_ip__classab_buffer_0.se_folded_cascode_np_ab_0.outa1n.n31 gf180mcu_ocd_ip__classab_buffer_0.se_folded_cascode_np_ab_0.outa1n 1.88308
R1470 gf180mcu_ocd_ip__classab_buffer_0.se_folded_cascode_np_ab_0.outa1n.n3 gf180mcu_ocd_ip__classab_buffer_0.se_folded_cascode_np_ab_0.outa1n.n2 1.79964
R1471 gf180mcu_ocd_ip__classab_buffer_0.se_folded_cascode_np_ab_0.outa1n.n4 gf180mcu_ocd_ip__classab_buffer_0.se_folded_cascode_np_ab_0.outa1n.n1 1.79536
R1472 gf180mcu_ocd_ip__classab_buffer_0.se_folded_cascode_np_ab_0.outa1n.n3 gf180mcu_ocd_ip__classab_buffer_0.se_folded_cascode_np_ab_0.outa1n.n1 1.79536
R1473 gf180mcu_ocd_ip__classab_buffer_0.se_folded_cascode_np_ab_0.outa1n.n88 gf180mcu_ocd_ip__classab_buffer_0.se_folded_cascode_np_ab_0.outa1n.n34 1.68479
R1474 gf180mcu_ocd_ip__classab_buffer_0.se_folded_cascode_np_ab_0.outa1n.n86 gf180mcu_ocd_ip__classab_buffer_0.se_folded_cascode_np_ab_0.outa1n.n35 1.68479
R1475 gf180mcu_ocd_ip__classab_buffer_0.se_folded_cascode_np_ab_0.outa1n.n36 gf180mcu_ocd_ip__classab_buffer_0.se_folded_cascode_np_ab_0.outa1n.n90 1.68479
R1476 gf180mcu_ocd_ip__classab_buffer_0.se_folded_cascode_np_ab_0.outa1n.n91 gf180mcu_ocd_ip__classab_buffer_0.se_folded_cascode_np_ab_0.outa1n.n10 1.68479
R1477 gf180mcu_ocd_ip__classab_buffer_0.se_folded_cascode_np_ab_0.outa1n.n84 gf180mcu_ocd_ip__classab_buffer_0.se_folded_cascode_np_ab_0.outa1n.n37 1.68479
R1478 gf180mcu_ocd_ip__classab_buffer_0.se_folded_cascode_np_ab_0.outa1n.n93 gf180mcu_ocd_ip__classab_buffer_0.se_folded_cascode_np_ab_0.outa1n.n38 1.68479
R1479 gf180mcu_ocd_ip__classab_buffer_0.se_folded_cascode_np_ab_0.outa1n.n72 gf180mcu_ocd_ip__classab_buffer_0.se_folded_cascode_np_ab_0.outa1n.n40 1.68479
R1480 gf180mcu_ocd_ip__classab_buffer_0.se_folded_cascode_np_ab_0.outa1n.n94 gf180mcu_ocd_ip__classab_buffer_0.se_folded_cascode_np_ab_0.outa1n.n42 1.68479
R1481 gf180mcu_ocd_ip__classab_buffer_0.se_folded_cascode_np_ab_0.outa1n.n43 gf180mcu_ocd_ip__classab_buffer_0.se_folded_cascode_np_ab_0.outa1n.n73 1.68479
R1482 gf180mcu_ocd_ip__classab_buffer_0.se_folded_cascode_np_ab_0.outa1n.n44 gf180mcu_ocd_ip__classab_buffer_0.se_folded_cascode_np_ab_0.outa1n.n22 1.68479
R1483 gf180mcu_ocd_ip__classab_buffer_0.se_folded_cascode_np_ab_0.outa1n.n83 gf180mcu_ocd_ip__classab_buffer_0.se_folded_cascode_np_ab_0.outa1n.n35 1.68479
R1484 gf180mcu_ocd_ip__classab_buffer_0.se_folded_cascode_np_ab_0.outa1n.n86 gf180mcu_ocd_ip__classab_buffer_0.se_folded_cascode_np_ab_0.outa1n.n34 1.68479
R1485 gf180mcu_ocd_ip__classab_buffer_0.se_folded_cascode_np_ab_0.outa1n.n80 gf180mcu_ocd_ip__classab_buffer_0.se_folded_cascode_np_ab_0.outa1n.n44 1.68479
R1486 gf180mcu_ocd_ip__classab_buffer_0.se_folded_cascode_np_ab_0.outa1n.n43 gf180mcu_ocd_ip__classab_buffer_0.se_folded_cascode_np_ab_0.outa1n.n22 1.68479
R1487 gf180mcu_ocd_ip__classab_buffer_0.se_folded_cascode_np_ab_0.outa1n.n73 gf180mcu_ocd_ip__classab_buffer_0.se_folded_cascode_np_ab_0.outa1n.n42 1.68479
R1488 gf180mcu_ocd_ip__classab_buffer_0.se_folded_cascode_np_ab_0.outa1n.n40 gf180mcu_ocd_ip__classab_buffer_0.se_folded_cascode_np_ab_0.outa1n.n39 1.68479
R1489 gf180mcu_ocd_ip__classab_buffer_0.se_folded_cascode_np_ab_0.outa1n.n72 gf180mcu_ocd_ip__classab_buffer_0.se_folded_cascode_np_ab_0.outa1n.n38 1.68479
R1490 gf180mcu_ocd_ip__classab_buffer_0.se_folded_cascode_np_ab_0.outa1n.n81 gf180mcu_ocd_ip__classab_buffer_0.se_folded_cascode_np_ab_0.outa1n.n37 1.68479
R1491 gf180mcu_ocd_ip__classab_buffer_0.se_folded_cascode_np_ab_0.outa1n.n84 gf180mcu_ocd_ip__classab_buffer_0.se_folded_cascode_np_ab_0.outa1n.n10 1.68479
R1492 gf180mcu_ocd_ip__classab_buffer_0.se_folded_cascode_np_ab_0.outa1n.n91 gf180mcu_ocd_ip__classab_buffer_0.se_folded_cascode_np_ab_0.outa1n.n36 1.68479
R1493 gf180mcu_ocd_ip__classab_buffer_0.se_folded_cascode_np_ab_0.outa1n.n62 gf180mcu_ocd_ip__classab_buffer_0.se_folded_cascode_np_ab_0.outa1n 1.66597
R1494 gf180mcu_ocd_ip__classab_buffer_0.se_folded_cascode_np_ab_0.outa1n.n53 gf180mcu_ocd_ip__classab_buffer_0.se_folded_cascode_np_ab_0.outa1n 1.66597
R1495 gf180mcu_ocd_ip__classab_buffer_0.se_folded_cascode_np_ab_0.outa1n.n54 gf180mcu_ocd_ip__classab_buffer_0.se_folded_cascode_np_ab_0.outa1n 1.66597
R1496 gf180mcu_ocd_ip__classab_buffer_0.se_folded_cascode_np_ab_0.outa1n.n76 gf180mcu_ocd_ip__classab_buffer_0.se_folded_cascode_np_ab_0.outa1n 1.66597
R1497 gf180mcu_ocd_ip__classab_buffer_0.se_folded_cascode_np_ab_0.outa1n.n70 gf180mcu_ocd_ip__classab_buffer_0.se_folded_cascode_np_ab_0.outa1n 1.66597
R1498 gf180mcu_ocd_ip__classab_buffer_0.se_folded_cascode_np_ab_0.outa1n.n52 gf180mcu_ocd_ip__classab_buffer_0.se_folded_cascode_np_ab_0.outa1n 1.66597
R1499 gf180mcu_ocd_ip__classab_buffer_0.se_folded_cascode_np_ab_0.outa1n.n51 gf180mcu_ocd_ip__classab_buffer_0.se_folded_cascode_np_ab_0.outa1n 1.66597
R1500 gf180mcu_ocd_ip__classab_buffer_0.se_folded_cascode_np_ab_0.outa1n.n74 gf180mcu_ocd_ip__classab_buffer_0.se_folded_cascode_np_ab_0.outa1n 1.66597
R1501 gf180mcu_ocd_ip__classab_buffer_0.se_folded_cascode_np_ab_0.outa1n.n71 gf180mcu_ocd_ip__classab_buffer_0.se_folded_cascode_np_ab_0.outa1n 1.66597
R1502 gf180mcu_ocd_ip__classab_buffer_0.se_folded_cascode_np_ab_0.outa1n.n69 gf180mcu_ocd_ip__classab_buffer_0.se_folded_cascode_np_ab_0.outa1n 1.66597
R1503 gf180mcu_ocd_ip__classab_buffer_0.se_folded_cascode_np_ab_0.outa1n.n68 gf180mcu_ocd_ip__classab_buffer_0.se_folded_cascode_np_ab_0.outa1n 1.66597
R1504 gf180mcu_ocd_ip__classab_buffer_0.se_folded_cascode_np_ab_0.outa1n.n49 gf180mcu_ocd_ip__classab_buffer_0.se_folded_cascode_np_ab_0.outa1n 1.66597
R1505 gf180mcu_ocd_ip__classab_buffer_0.se_folded_cascode_np_ab_0.outa1n.n48 gf180mcu_ocd_ip__classab_buffer_0.se_folded_cascode_np_ab_0.outa1n 1.66597
R1506 gf180mcu_ocd_ip__classab_buffer_0.se_folded_cascode_np_ab_0.outa1n.n55 gf180mcu_ocd_ip__classab_buffer_0.se_folded_cascode_np_ab_0.outa1n 1.66597
R1507 gf180mcu_ocd_ip__classab_buffer_0.se_folded_cascode_np_ab_0.outa1n.n56 gf180mcu_ocd_ip__classab_buffer_0.se_folded_cascode_np_ab_0.outa1n 1.66597
R1508 gf180mcu_ocd_ip__classab_buffer_0.se_folded_cascode_np_ab_0.outa1n.n58 gf180mcu_ocd_ip__classab_buffer_0.se_folded_cascode_np_ab_0.outa1n 1.66597
R1509 gf180mcu_ocd_ip__classab_buffer_0.se_folded_cascode_np_ab_0.outa1n.n59 gf180mcu_ocd_ip__classab_buffer_0.se_folded_cascode_np_ab_0.outa1n 1.66597
R1510 gf180mcu_ocd_ip__classab_buffer_0.se_folded_cascode_np_ab_0.outa1n.n61 gf180mcu_ocd_ip__classab_buffer_0.se_folded_cascode_np_ab_0.outa1n 1.66597
R1511 gf180mcu_ocd_ip__classab_buffer_0.se_folded_cascode_np_ab_0.outa1n.n63 gf180mcu_ocd_ip__classab_buffer_0.se_folded_cascode_np_ab_0.outa1n 1.66597
R1512 gf180mcu_ocd_ip__classab_buffer_0.se_folded_cascode_np_ab_0.outa1n.n64 gf180mcu_ocd_ip__classab_buffer_0.se_folded_cascode_np_ab_0.outa1n 1.66597
R1513 gf180mcu_ocd_ip__classab_buffer_0.se_folded_cascode_np_ab_0.outa1n.n66 gf180mcu_ocd_ip__classab_buffer_0.se_folded_cascode_np_ab_0.outa1n 1.66597
R1514 gf180mcu_ocd_ip__classab_buffer_0.se_folded_cascode_np_ab_0.outa1n.n78 gf180mcu_ocd_ip__classab_buffer_0.se_folded_cascode_np_ab_0.outa1n 1.66597
R1515 gf180mcu_ocd_ip__classab_buffer_0.se_folded_cascode_np_ab_0.outa1n.n77 gf180mcu_ocd_ip__classab_buffer_0.se_folded_cascode_np_ab_0.outa1n 1.66597
R1516 gf180mcu_ocd_ip__classab_buffer_0.se_folded_cascode_np_ab_0.outa1n.n75 gf180mcu_ocd_ip__classab_buffer_0.se_folded_cascode_np_ab_0.outa1n 1.66597
R1517 gf180mcu_ocd_ip__classab_buffer_0.se_folded_cascode_np_ab_0.outa1n gf180mcu_ocd_ip__classab_buffer_0.se_folded_cascode_np_ab_0.outa1n.n2 1.45421
R1518 gf180mcu_ocd_ip__classab_buffer_0.se_folded_cascode_np_ab_0.outa1n.n21 gf180mcu_ocd_ip__classab_buffer_0.se_folded_cascode_np_ab_0.outa1n.n20 1.4405
R1519 gf180mcu_ocd_ip__classab_buffer_0.se_folded_cascode_np_ab_0.outa1n.n18 gf180mcu_ocd_ip__classab_buffer_0.se_folded_cascode_np_ab_0.outa1n.n0 1.4405
R1520 gf180mcu_ocd_ip__classab_buffer_0.se_folded_cascode_np_ab_0.outa1n.n85 gf180mcu_ocd_ip__classab_buffer_0.se_folded_cascode_np_ab_0.outa1n.n16 1.4405
R1521 gf180mcu_ocd_ip__classab_buffer_0.se_folded_cascode_np_ab_0.outa1n.n15 gf180mcu_ocd_ip__classab_buffer_0.se_folded_cascode_np_ab_0.outa1n.n14 1.4405
R1522 gf180mcu_ocd_ip__classab_buffer_0.se_folded_cascode_np_ab_0.outa1n.n82 gf180mcu_ocd_ip__classab_buffer_0.se_folded_cascode_np_ab_0.outa1n.n13 1.4405
R1523 gf180mcu_ocd_ip__classab_buffer_0.se_folded_cascode_np_ab_0.outa1n.n87 gf180mcu_ocd_ip__classab_buffer_0.se_folded_cascode_np_ab_0.outa1n.n11 1.4405
R1524 gf180mcu_ocd_ip__classab_buffer_0.se_folded_cascode_np_ab_0.outa1n.n23 gf180mcu_ocd_ip__classab_buffer_0.se_folded_cascode_np_ab_0.outa1n.n16 1.4145
R1525 gf180mcu_ocd_ip__classab_buffer_0.se_folded_cascode_np_ab_0.outa1n.n18 gf180mcu_ocd_ip__classab_buffer_0.se_folded_cascode_np_ab_0.outa1n.n17 1.3978
R1526 gf180mcu_ocd_ip__classab_buffer_0.se_folded_cascode_np_ab_0.outa1n.n32 gf180mcu_ocd_ip__classab_buffer_0.se_folded_cascode_np_ab_0.outa1n.n30 1.38483
R1527 gf180mcu_ocd_ip__classab_buffer_0.se_folded_cascode_np_ab_0.outa1n.n5 gf180mcu_ocd_ip__classab_buffer_0.se_folded_cascode_np_ab_0.outa1n.n31 1.3737
R1528 gf180mcu_ocd_ip__classab_buffer_0.se_folded_cascode_np_ab_0.outa1n.n45 gf180mcu_ocd_ip__classab_buffer_0.se_folded_cascode_np_ab_0.outa1n.n33 1.36906
R1529 gf180mcu_ocd_ip__classab_buffer_0.se_folded_cascode_np_ab_0.outa1n.n27 gf180mcu_ocd_ip__classab_buffer_0.se_folded_cascode_np_ab_0.outa1n.n21 1.33106
R1530 gf180mcu_ocd_ip__classab_buffer_0.se_folded_cascode_np_ab_0.outa1n.n28 gf180mcu_ocd_ip__classab_buffer_0.se_folded_cascode_np_ab_0.outa1n.n15 1.31743
R1531 gf180mcu_ocd_ip__classab_buffer_0.se_folded_cascode_np_ab_0.outa1n.n29 gf180mcu_ocd_ip__classab_buffer_0.se_folded_cascode_np_ab_0.outa1n.n11 1.30719
R1532 gf180mcu_ocd_ip__classab_buffer_0.se_folded_cascode_np_ab_0.outa1n.n13 gf180mcu_ocd_ip__classab_buffer_0.se_folded_cascode_np_ab_0.outa1n.n12 1.26203
R1533 gf180mcu_ocd_ip__classab_buffer_0.se_folded_cascode_np_ab_0.outa1n.n25 gf180mcu_ocd_ip__classab_buffer_0.se_folded_cascode_np_ab_0.outa1n.n24 1.25073
R1534 gf180mcu_ocd_ip__classab_buffer_0.se_folded_cascode_np_ab_0.outa1n.n95 gf180mcu_ocd_ip__classab_buffer_0.se_folded_cascode_np_ab_0.outa1n.n26 1.23439
R1535 gf180mcu_ocd_ip__classab_buffer_0.se_folded_cascode_np_ab_0.outa1n.n93 gf180mcu_ocd_ip__classab_buffer_0.se_folded_cascode_np_ab_0.outa1n.n92 1.18657
R1536 gf180mcu_ocd_ip__classab_buffer_0.se_folded_cascode_np_ab_0.outa1n.n89 gf180mcu_ocd_ip__classab_buffer_0.se_folded_cascode_np_ab_0.outa1n.n88 1.18336
R1537 gf180mcu_ocd_ip__classab_buffer_0.se_folded_cascode_np_ab_0.outa1n.n33 gf180mcu_ocd_ip__classab_buffer_0.se_folded_cascode_np_ab_0.outa1n.n32 1.12596
R1538 x1.xamp.vbp1.n23 x1.xamp.vbp1.t16 12.1505
R1539 x1.xamp.vbp1.n24 x1.xamp.vbp1.t17 12.1505
R1540 x1.xamp.vbp1.n25 x1.xamp.vbp1.t18 12.1505
R1541 x1.xamp.vbp1.n26 x1.xamp.vbp1.t19 12.1505
R1542 x1.xamp.vbp1.n27 x1.xamp.vbp1.t20 12.1505
R1543 x1.xamp.vbp1.n28 x1.xamp.vbp1.t21 12.1505
R1544 x1.xamp.vbp1.n29 x1.xamp.vbp1.t22 12.1505
R1545 x1.xamp.vbp1.n30 x1.xamp.vbp1.t23 12.1505
R1546 x1.xamp.vbp1.n31 x1.xamp.vbp1.t24 12.1505
R1547 x1.xamp.vbp1.n36 x1.xamp.vbp1.t29 12.1505
R1548 x1.xamp.vbp1.n37 x1.xamp.vbp1.t30 12.1505
R1549 x1.xamp.vbp1.n38 x1.xamp.vbp1.t31 12.1505
R1550 x1.xamp.vbp1.n39 x1.xamp.vbp1.t32 12.1505
R1551 x1.xamp.vbp1.n15 x1.xamp.vbp1.n16 2.41437
R1552 x1.xamp.vbp1.n40 x1.xamp.vbp1.t33 12.1505
R1553 x1.xamp.vbp1.n17 x1.xamp.vbp1.n18 2.41437
R1554 x1.xamp.vbp1.n41 x1.xamp.vbp1.t34 12.1505
R1555 x1.xamp.vbp1.n19 x1.xamp.vbp1.n20 2.41437
R1556 x1.xamp.vbp1.n42 x1.xamp.vbp1.t35 12.1505
R1557 x1.xamp.vbp1.n21 x1.xamp.vbp1.n22 2.41437
R1558 x1.xamp.vbp1.t16 x1.xamp.vbp1 7.6505
R1559 x1.xamp.vbp1.t17 x1.xamp.vbp1 7.6505
R1560 x1.xamp.vbp1.t18 x1.xamp.vbp1 7.6505
R1561 x1.xamp.vbp1.t19 x1.xamp.vbp1 7.6505
R1562 x1.xamp.vbp1.t20 x1.xamp.vbp1 7.6505
R1563 x1.xamp.vbp1.t21 x1.xamp.vbp1 7.6505
R1564 x1.xamp.vbp1.t22 x1.xamp.vbp1 7.6505
R1565 x1.xamp.vbp1.t23 x1.xamp.vbp1 7.6505
R1566 x1.xamp.vbp1.t24 x1.xamp.vbp1 7.6505
R1567 x1.xamp.vbp1.t29 x1.xamp.vbp1 7.6505
R1568 x1.xamp.vbp1.t30 x1.xamp.vbp1 7.6505
R1569 x1.xamp.vbp1.t31 x1.xamp.vbp1 7.6505
R1570 x1.xamp.vbp1.t32 x1.xamp.vbp1 7.6505
R1571 x1.xamp.vbp1.t6 x1.xamp.vbp1.n16 3.76288
R1572 x1.xamp.vbp1.t33 x1.xamp.vbp1 7.6505
R1573 x1.xamp.vbp1.t4 x1.xamp.vbp1.n18 3.76288
R1574 x1.xamp.vbp1.t34 x1.xamp.vbp1 7.6505
R1575 x1.xamp.vbp1.t2 x1.xamp.vbp1.n20 3.76288
R1576 x1.xamp.vbp1.t35 x1.xamp.vbp1 7.6505
R1577 x1.xamp.vbp1.t0 x1.xamp.vbp1.n22 3.76288
R1578 x1.xamp.vbp1.n23 x1.xamp.vbp1 4.90824
R1579 x1.xamp.vbp1.n24 x1.xamp.vbp1 4.90824
R1580 x1.xamp.vbp1.n25 x1.xamp.vbp1 4.90824
R1581 x1.xamp.vbp1.n26 x1.xamp.vbp1 4.90824
R1582 x1.xamp.vbp1.n27 x1.xamp.vbp1 4.90824
R1583 x1.xamp.vbp1.n28 x1.xamp.vbp1 4.90824
R1584 x1.xamp.vbp1.n29 x1.xamp.vbp1 4.90824
R1585 x1.xamp.vbp1.n30 x1.xamp.vbp1 4.90824
R1586 x1.xamp.vbp1.n31 x1.xamp.vbp1 4.90824
R1587 x1.xamp.vbp1.n36 x1.xamp.vbp1 4.90824
R1588 x1.xamp.vbp1.n37 x1.xamp.vbp1 4.90824
R1589 x1.xamp.vbp1.n38 x1.xamp.vbp1 4.90824
R1590 x1.xamp.vbp1.n39 x1.xamp.vbp1 4.90824
R1591 x1.xamp.vbp1.n16 x1.xamp.vbp1 1.52053
R1592 x1.xamp.vbp1.n40 x1.xamp.vbp1 4.90824
R1593 x1.xamp.vbp1.n18 x1.xamp.vbp1 1.52053
R1594 x1.xamp.vbp1.n41 x1.xamp.vbp1 4.90824
R1595 x1.xamp.vbp1.n20 x1.xamp.vbp1 1.52053
R1596 x1.xamp.vbp1.n42 x1.xamp.vbp1 4.90824
R1597 x1.xamp.vbp1.n22 x1.xamp.vbp1 1.52053
R1598 x1.xamp.vbp1.n8 x1.xamp.vbp1.n32 4.66508
R1599 x1.xamp.vbp1.n9 x1.xamp.vbp1.n33 4.66508
R1600 x1.xamp.vbp1.n9 x1.xamp.vbp1.n34 4.66508
R1601 x1.xamp.vbp1.n10 x1.xamp.vbp1.n35 4.66455
R1602 x1.xamp.vbp1 x1.xamp.vbp1.t7 4.4205
R1603 x1.xamp.vbp1 x1.xamp.vbp1.t5 4.4205
R1604 x1.xamp.vbp1 x1.xamp.vbp1.t3 4.4205
R1605 x1.xamp.vbp1 x1.xamp.vbp1.t1 4.4205
R1606 x1.xamp.vbp1.n35 x1.xamp.vbp1.t28 3.76316
R1607 x1.xamp.vbp1.n32 x1.xamp.vbp1.t25 3.76261
R1608 x1.xamp.vbp1.n33 x1.xamp.vbp1.t26 3.76261
R1609 x1.xamp.vbp1.n34 x1.xamp.vbp1.t27 3.76261
R1610 x1.xamp.vbp1.n0 x1.xamp.vbp1.n4 2.65492
R1611 x1.xamp.vbp1.n15 x1.xamp.vbp1 2.6411
R1612 x1.xamp.vbp1.n17 x1.xamp.vbp1 2.6411
R1613 x1.xamp.vbp1.n19 x1.xamp.vbp1 2.6411
R1614 x1.xamp.vbp1.n21 x1.xamp.vbp1 2.6411
R1615 x1.xamp.vbp1.n1 x1.xamp.vbp1 2.25591
R1616 x1.xamp.vbp1 x1.xamp.vbp1.n23 2.25228
R1617 x1.xamp.vbp1 x1.xamp.vbp1.n24 2.25228
R1618 x1.xamp.vbp1.n5 x1.xamp.vbp1.n25 2.25228
R1619 x1.xamp.vbp1.n6 x1.xamp.vbp1.n26 2.25228
R1620 x1.xamp.vbp1.n6 x1.xamp.vbp1.n27 2.25228
R1621 x1.xamp.vbp1.n7 x1.xamp.vbp1.n28 2.25228
R1622 x1.xamp.vbp1.n7 x1.xamp.vbp1.n29 2.25228
R1623 x1.xamp.vbp1.n8 x1.xamp.vbp1.n30 2.25228
R1624 x1.xamp.vbp1.n8 x1.xamp.vbp1.n31 2.25228
R1625 x1.xamp.vbp1.n10 x1.xamp.vbp1.n36 2.25228
R1626 x1.xamp.vbp1.n11 x1.xamp.vbp1.n37 2.25228
R1627 x1.xamp.vbp1.n11 x1.xamp.vbp1.n38 2.25228
R1628 x1.xamp.vbp1.n12 x1.xamp.vbp1.n39 2.25228
R1629 x1.xamp.vbp1.n13 x1.xamp.vbp1.n40 2.25228
R1630 x1.xamp.vbp1.n14 x1.xamp.vbp1.n41 2.25228
R1631 x1.xamp.vbp1.n0 x1.xamp.vbp1.n42 2.25228
R1632 x1.xamp.vbp1.n0 x1.xamp.vbp1.n21 2.25228
R1633 x1.xamp.vbp1.n14 x1.xamp.vbp1.n19 2.25228
R1634 x1.xamp.vbp1.n13 x1.xamp.vbp1.n17 2.25228
R1635 x1.xamp.vbp1.n12 x1.xamp.vbp1.n15 2.25228
R1636 x1.xamp.vbp1.n2 x1.xamp.vbp1.n0 2.2505
R1637 x1.xamp.vbp1 x1.xamp.vbp1.t14 2.24722
R1638 x1.xamp.vbp1 x1.xamp.vbp1.t13 2.24722
R1639 x1.xamp.vbp1 x1.xamp.vbp1.t12 2.24722
R1640 x1.xamp.vbp1 x1.xamp.vbp1.t11 2.24722
R1641 x1.xamp.vbp1 x1.xamp.vbp1.t8 2.24722
R1642 x1.xamp.vbp1 x1.xamp.vbp1.t9 2.24722
R1643 x1.xamp.vbp1 x1.xamp.vbp1.t10 2.24722
R1644 x1.xamp.vbp1.n3 x1.xamp.vbp1 2.22322
R1645 x1.xamp.vbp1 x1.xamp.vbp1.n2 1.66312
R1646 x1.xamp.vbp1.n4 x1.xamp.vbp1 1.65793
R1647 x1.xamp.vbp1.n0 x1.xamp.vbp1.n14 1.59712
R1648 x1.xamp.vbp1 x1.xamp.vbp1.t15 1.57122
R1649 x1.xamp.vbp1.n9 x1.xamp.vbp1.n8 1.54803
R1650 x1.xamp.vbp1.n32 x1.xamp.vbp1 1.52097
R1651 x1.xamp.vbp1.n33 x1.xamp.vbp1 1.52097
R1652 x1.xamp.vbp1.n34 x1.xamp.vbp1 1.52097
R1653 x1.xamp.vbp1.n35 x1.xamp.vbp1 1.52042
R1654 x1.xamp.vbp1.n1 x1.xamp.vbp1 1.5005
R1655 x1.xamp.vbp1.n2 x1.xamp.vbp1 1.5005
R1656 x1.xamp.vbp1.n4 x1.xamp.vbp1 1.5005
R1657 x1.xamp.vbp1.n3 x1.xamp.vbp1 1.5005
R1658 x1.xamp.vbp1.n2 x1.xamp.vbp1.n1 1.29919
R1659 x1.xamp.vbp1.n4 x1.xamp.vbp1.n3 1.25164
R1660 x1.xamp.vbp1.n10 x1.xamp.vbp1.n9 1.03608
R1661 x1.xamp.vbp1.n5 x1.xamp.vbp1 1.03375
R1662 x1.xamp.vbp1.n14 x1.xamp.vbp1.n13 1.03375
R1663 x1.xamp.vbp1.n13 x1.xamp.vbp1.n12 1.03375
R1664 x1.xamp.vbp1.n12 x1.xamp.vbp1.n11 1.03375
R1665 x1.xamp.vbp1.n11 x1.xamp.vbp1.n10 1.03375
R1666 x1.xamp.vbp1.n8 x1.xamp.vbp1.n7 1.03375
R1667 x1.xamp.vbp1.n7 x1.xamp.vbp1.n6 1.03375
R1668 x1.xamp.vbp1.n6 x1.xamp.vbp1.n5 1.03375
R1669 x1.xamp.pfet_03v3_EQVFPB_0.G1_0.n53 x1.xamp.pfet_03v3_EQVFPB_0.G1_0 13.7705
R1670 x1.xamp.pfet_03v3_EQVFPB_0.G1_0.n9 x1.xamp.pfet_03v3_EQVFPB_0.G1_0.t25 1.669
R1671 x1.xamp.pfet_03v3_EQVFPB_0.G1_0.n11 x1.xamp.pfet_03v3_EQVFPB_0.G1_0.t29 7.8365
R1672 x1.xamp.pfet_03v3_EQVFPB_0.G1_0.n13 x1.xamp.pfet_03v3_EQVFPB_0.G1_0.t33 7.8365
R1673 x1.xamp.pfet_03v3_EQVFPB_0.G1_0.n15 x1.xamp.pfet_03v3_EQVFPB_0.G1_0.t37 7.8365
R1674 x1.xamp.pfet_03v3_EQVFPB_0.G1_0.n23 x1.xamp.pfet_03v3_EQVFPB_0.G1_0.t27 7.8365
R1675 x1.xamp.pfet_03v3_EQVFPB_0.G1_0.n21 x1.xamp.pfet_03v3_EQVFPB_0.G1_0.t31 7.8365
R1676 x1.xamp.pfet_03v3_EQVFPB_0.G1_0.n19 x1.xamp.pfet_03v3_EQVFPB_0.G1_0.t35 7.8365
R1677 x1.xamp.pfet_03v3_EQVFPB_0.G1_0.n17 x1.xamp.pfet_03v3_EQVFPB_0.G1_0.t39 7.8365
R1678 x1.xamp.pfet_03v3_EQVFPB_0.G1_0.n39 x1.xamp.pfet_03v3_EQVFPB_0.G1_0 7.23128
R1679 x1.xamp.pfet_03v3_EQVFPB_0.G1_0.n5 x1.xamp.pfet_03v3_EQVFPB_0.G1_0 7.16611
R1680 x1.xamp.pfet_03v3_EQVFPB_0.G1_0 x1.xamp.pfet_03v3_EQVFPB_0.G1_0.n54 7.16198
R1681 x1.xamp.pfet_03v3_EQVFPB_0.G1_0.n51 x1.xamp.pfet_03v3_EQVFPB_0.G1_0 6.97735
R1682 x1.xamp.pfet_03v3_EQVFPB_0.G1_0.n27 x1.xamp.pfet_03v3_EQVFPB_0.G1_0 6.97735
R1683 x1.xamp.pfet_03v3_EQVFPB_0.G1_0.n28 x1.xamp.pfet_03v3_EQVFPB_0.G1_0 6.97735
R1684 x1.xamp.pfet_03v3_EQVFPB_0.G1_0.n24 x1.xamp.pfet_03v3_EQVFPB_0.G1_0 6.95762
R1685 x1.xamp.pfet_03v3_EQVFPB_0.G1_0.n25 x1.xamp.pfet_03v3_EQVFPB_0.G1_0 6.95762
R1686 x1.xamp.pfet_03v3_EQVFPB_0.G1_0.n26 x1.xamp.pfet_03v3_EQVFPB_0.G1_0 6.95762
R1687 x1.xamp.pfet_03v3_EQVFPB_0.G1_0.n52 x1.xamp.pfet_03v3_EQVFPB_0.G1_0.n24 6.74303
R1688 x1.xamp.pfet_03v3_EQVFPB_0.G1_0.n38 x1.xamp.pfet_03v3_EQVFPB_0.G1_0.n26 6.48749
R1689 x1.xamp.pfet_03v3_EQVFPB_0.G1_0.n5 x1.xamp.pfet_03v3_EQVFPB_0.G1_0 6.28607
R1690 x1.xamp.pfet_03v3_EQVFPB_0.G1_0.n5 x1.xamp.pfet_03v3_EQVFPB_0.G1_0 6.28607
R1691 x1.xamp.pfet_03v3_EQVFPB_0.G1_0.n49 x1.xamp.pfet_03v3_EQVFPB_0.G1_0.n24 5.06839
R1692 x1.xamp.pfet_03v3_EQVFPB_0.G1_0.n47 x1.xamp.pfet_03v3_EQVFPB_0.G1_0.n46 5.06839
R1693 x1.xamp.pfet_03v3_EQVFPB_0.G1_0.n25 x1.xamp.pfet_03v3_EQVFPB_0.G1_0.n45 5.06839
R1694 x1.xamp.pfet_03v3_EQVFPB_0.G1_0.n43 x1.xamp.pfet_03v3_EQVFPB_0.G1_0.n42 5.06839
R1695 x1.xamp.pfet_03v3_EQVFPB_0.G1_0.n26 x1.xamp.pfet_03v3_EQVFPB_0.G1_0.n41 5.06839
R1696 x1.xamp.pfet_03v3_EQVFPB_0.G1_0.n52 x1.xamp.pfet_03v3_EQVFPB_0.G1_0.n51 4.75443
R1697 x1.xamp.pfet_03v3_EQVFPB_0.G1_0.n4 x1.xamp.pfet_03v3_EQVFPB_0.G1_0.n2 4.73507
R1698 x1.xamp.pfet_03v3_EQVFPB_0.G1_0.n48 x1.xamp.pfet_03v3_EQVFPB_0.G1_0.n0 4.72996
R1699 x1.xamp.pfet_03v3_EQVFPB_0.G1_0.n0 x1.xamp.pfet_03v3_EQVFPB_0.G1_0.n7 4.7274
R1700 x1.xamp.pfet_03v3_EQVFPB_0.G1_0.n54 x1.xamp.pfet_03v3_EQVFPB_0.G1_0.n53 4.72667
R1701 x1.xamp.pfet_03v3_EQVFPB_0.G1_0 x1.xamp.pfet_03v3_EQVFPB_0.G1_0.t7 4.62903
R1702 x1.xamp.pfet_03v3_EQVFPB_0.G1_0 x1.xamp.pfet_03v3_EQVFPB_0.G1_0.t5 4.62903
R1703 x1.xamp.pfet_03v3_EQVFPB_0.G1_0 x1.xamp.pfet_03v3_EQVFPB_0.G1_0.t6 4.62903
R1704 x1.xamp.pfet_03v3_EQVFPB_0.G1_0 x1.xamp.pfet_03v3_EQVFPB_0.G1_0.t4 4.62903
R1705 x1.xamp.pfet_03v3_EQVFPB_0.G1_0 x1.xamp.pfet_03v3_EQVFPB_0.G1_0.t2 4.62903
R1706 x1.xamp.pfet_03v3_EQVFPB_0.G1_0 x1.xamp.pfet_03v3_EQVFPB_0.G1_0.t0 4.62903
R1707 x1.xamp.pfet_03v3_EQVFPB_0.G1_0 x1.xamp.pfet_03v3_EQVFPB_0.G1_0.t3 4.62903
R1708 x1.xamp.pfet_03v3_EQVFPB_0.G1_0 x1.xamp.pfet_03v3_EQVFPB_0.G1_0.t1 4.62903
R1709 x1.xamp.pfet_03v3_EQVFPB_0.G1_0.n6 x1.xamp.pfet_03v3_EQVFPB_0.G1_0.n17 4.5005
R1710 x1.xamp.pfet_03v3_EQVFPB_0.G1_0.n15 x1.xamp.pfet_03v3_EQVFPB_0.G1_0.n6 4.5005
R1711 x1.xamp.pfet_03v3_EQVFPB_0.G1_0.n4 x1.xamp.pfet_03v3_EQVFPB_0.G1_0.n19 4.5005
R1712 x1.xamp.pfet_03v3_EQVFPB_0.G1_0.n3 x1.xamp.pfet_03v3_EQVFPB_0.G1_0.n13 4.5005
R1713 x1.xamp.pfet_03v3_EQVFPB_0.G1_0.n0 x1.xamp.pfet_03v3_EQVFPB_0.G1_0.n21 4.5005
R1714 x1.xamp.pfet_03v3_EQVFPB_0.G1_0.n0 x1.xamp.pfet_03v3_EQVFPB_0.G1_0.n11 4.5005
R1715 x1.xamp.pfet_03v3_EQVFPB_0.G1_0.n1 x1.xamp.pfet_03v3_EQVFPB_0.G1_0.n23 4.5005
R1716 x1.xamp.pfet_03v3_EQVFPB_0.G1_0.n1 x1.xamp.pfet_03v3_EQVFPB_0.G1_0.n29 4.5005
R1717 x1.xamp.pfet_03v3_EQVFPB_0.G1_0.n9 x1.xamp.pfet_03v3_EQVFPB_0.G1_0.n8 2.251
R1718 x1.xamp.pfet_03v3_EQVFPB_0.G1_0.n50 x1.xamp.pfet_03v3_EQVFPB_0.G1_0.n49 4.5005
R1719 x1.xamp.pfet_03v3_EQVFPB_0.G1_0.n39 x1.xamp.pfet_03v3_EQVFPB_0.G1_0.n38 4.5005
R1720 x1.xamp.pfet_03v3_EQVFPB_0.G1_0.n41 x1.xamp.pfet_03v3_EQVFPB_0.G1_0.n40 4.5005
R1721 x1.xamp.pfet_03v3_EQVFPB_0.G1_0.n28 x1.xamp.pfet_03v3_EQVFPB_0.G1_0.n43 4.5005
R1722 x1.xamp.pfet_03v3_EQVFPB_0.G1_0.n45 x1.xamp.pfet_03v3_EQVFPB_0.G1_0.n44 4.5005
R1723 x1.xamp.pfet_03v3_EQVFPB_0.G1_0.n47 x1.xamp.pfet_03v3_EQVFPB_0.G1_0.n27 4.5005
R1724 x1.xamp.pfet_03v3_EQVFPB_0.G1_0 x1.xamp.pfet_03v3_EQVFPB_0.G1_0.n10 4.5005
R1725 x1.xamp.pfet_03v3_EQVFPB_0.G1_0 x1.xamp.pfet_03v3_EQVFPB_0.G1_0.n12 4.5005
R1726 x1.xamp.pfet_03v3_EQVFPB_0.G1_0 x1.xamp.pfet_03v3_EQVFPB_0.G1_0.n14 4.5005
R1727 x1.xamp.pfet_03v3_EQVFPB_0.G1_0 x1.xamp.pfet_03v3_EQVFPB_0.G1_0.n22 4.5005
R1728 x1.xamp.pfet_03v3_EQVFPB_0.G1_0 x1.xamp.pfet_03v3_EQVFPB_0.G1_0.n20 4.5005
R1729 x1.xamp.pfet_03v3_EQVFPB_0.G1_0 x1.xamp.pfet_03v3_EQVFPB_0.G1_0.n18 4.5005
R1730 x1.xamp.pfet_03v3_EQVFPB_0.G1_0 x1.xamp.pfet_03v3_EQVFPB_0.G1_0.n16 4.5005
R1731 x1.xamp.pfet_03v3_EQVFPB_0.G1_0.n9 x1.xamp.pfet_03v3_EQVFPB_0.G1_0 0.958887
R1732 x1.xamp.pfet_03v3_EQVFPB_0.G1_0.t29 x1.xamp.pfet_03v3_EQVFPB_0.G1_0 3.3365
R1733 x1.xamp.pfet_03v3_EQVFPB_0.G1_0.t33 x1.xamp.pfet_03v3_EQVFPB_0.G1_0 3.3365
R1734 x1.xamp.pfet_03v3_EQVFPB_0.G1_0.t37 x1.xamp.pfet_03v3_EQVFPB_0.G1_0 3.3365
R1735 x1.xamp.pfet_03v3_EQVFPB_0.G1_0.t27 x1.xamp.pfet_03v3_EQVFPB_0.G1_0 3.3365
R1736 x1.xamp.pfet_03v3_EQVFPB_0.G1_0.t31 x1.xamp.pfet_03v3_EQVFPB_0.G1_0 3.3365
R1737 x1.xamp.pfet_03v3_EQVFPB_0.G1_0.t35 x1.xamp.pfet_03v3_EQVFPB_0.G1_0 3.3365
R1738 x1.xamp.pfet_03v3_EQVFPB_0.G1_0.t39 x1.xamp.pfet_03v3_EQVFPB_0.G1_0 3.3365
R1739 x1.xamp.pfet_03v3_EQVFPB_0.G1_0.n8 x1.xamp.pfet_03v3_EQVFPB_0.G1_0.n31 2.69737
R1740 x1.xamp.pfet_03v3_EQVFPB_0.G1_0.n10 x1.xamp.pfet_03v3_EQVFPB_0.G1_0.n33 2.69737
R1741 x1.xamp.pfet_03v3_EQVFPB_0.G1_0.n12 x1.xamp.pfet_03v3_EQVFPB_0.G1_0.n36 2.69737
R1742 x1.xamp.pfet_03v3_EQVFPB_0.G1_0.n14 x1.xamp.pfet_03v3_EQVFPB_0.G1_0.n34 2.69737
R1743 x1.xamp.pfet_03v3_EQVFPB_0.G1_0.n22 x1.xamp.pfet_03v3_EQVFPB_0.G1_0.n30 2.69737
R1744 x1.xamp.pfet_03v3_EQVFPB_0.G1_0.n20 x1.xamp.pfet_03v3_EQVFPB_0.G1_0.n32 2.69737
R1745 x1.xamp.pfet_03v3_EQVFPB_0.G1_0.n18 x1.xamp.pfet_03v3_EQVFPB_0.G1_0.n37 2.69737
R1746 x1.xamp.pfet_03v3_EQVFPB_0.G1_0.n16 x1.xamp.pfet_03v3_EQVFPB_0.G1_0.n35 2.69737
R1747 x1.xamp.pfet_03v3_EQVFPB_0.G1_0.n3 x1.xamp.pfet_03v3_EQVFPB_0.G1_0.n0 2.63879
R1748 x1.xamp.pfet_03v3_EQVFPB_0.G1_0 x1.xamp.pfet_03v3_EQVFPB_0.G1_0.t22 2.25015
R1749 x1.xamp.pfet_03v3_EQVFPB_0.G1_0 x1.xamp.pfet_03v3_EQVFPB_0.G1_0.t19 2.25015
R1750 x1.xamp.pfet_03v3_EQVFPB_0.G1_0 x1.xamp.pfet_03v3_EQVFPB_0.G1_0.t18 2.25015
R1751 x1.xamp.pfet_03v3_EQVFPB_0.G1_0 x1.xamp.pfet_03v3_EQVFPB_0.G1_0.t16 2.25015
R1752 x1.xamp.pfet_03v3_EQVFPB_0.G1_0 x1.xamp.pfet_03v3_EQVFPB_0.G1_0.t15 2.25015
R1753 x1.xamp.pfet_03v3_EQVFPB_0.G1_0 x1.xamp.pfet_03v3_EQVFPB_0.G1_0.t13 2.25015
R1754 x1.xamp.pfet_03v3_EQVFPB_0.G1_0 x1.xamp.pfet_03v3_EQVFPB_0.G1_0.t12 2.25015
R1755 x1.xamp.pfet_03v3_EQVFPB_0.G1_0 x1.xamp.pfet_03v3_EQVFPB_0.G1_0.t21 2.25015
R1756 x1.xamp.pfet_03v3_EQVFPB_0.G1_0 x1.xamp.pfet_03v3_EQVFPB_0.G1_0.t20 2.25015
R1757 x1.xamp.pfet_03v3_EQVFPB_0.G1_0 x1.xamp.pfet_03v3_EQVFPB_0.G1_0.t17 2.25015
R1758 x1.xamp.pfet_03v3_EQVFPB_0.G1_0 x1.xamp.pfet_03v3_EQVFPB_0.G1_0.t14 2.25015
R1759 x1.xamp.pfet_03v3_EQVFPB_0.G1_0 x1.xamp.pfet_03v3_EQVFPB_0.G1_0.t11 2.25015
R1760 x1.xamp.pfet_03v3_EQVFPB_0.G1_0 x1.xamp.pfet_03v3_EQVFPB_0.G1_0.t10 2.25015
R1761 x1.xamp.pfet_03v3_EQVFPB_0.G1_0 x1.xamp.pfet_03v3_EQVFPB_0.G1_0.t9 2.25015
R1762 x1.xamp.pfet_03v3_EQVFPB_0.G1_0 x1.xamp.pfet_03v3_EQVFPB_0.G1_0.t8 2.25015
R1763 x1.xamp.pfet_03v3_EQVFPB_0.G1_0.n42 x1.xamp.pfet_03v3_EQVFPB_0.G1_0.n26 1.93068
R1764 x1.xamp.pfet_03v3_EQVFPB_0.G1_0.n17 x1.xamp.pfet_03v3_EQVFPB_0.G1_0 1.78109
R1765 x1.xamp.pfet_03v3_EQVFPB_0.G1_0.n21 x1.xamp.pfet_03v3_EQVFPB_0.G1_0 1.77869
R1766 x1.xamp.pfet_03v3_EQVFPB_0.G1_0.n23 x1.xamp.pfet_03v3_EQVFPB_0.G1_0 1.77597
R1767 x1.xamp.pfet_03v3_EQVFPB_0.G1_0.n6 x1.xamp.pfet_03v3_EQVFPB_0.G1_0.n5 1.76707
R1768 x1.xamp.pfet_03v3_EQVFPB_0.G1_0.n6 x1.xamp.pfet_03v3_EQVFPB_0.G1_0.n4 1.75936
R1769 x1.xamp.pfet_03v3_EQVFPB_0.G1_0.n4 x1.xamp.pfet_03v3_EQVFPB_0.G1_0.n3 1.75936
R1770 x1.xamp.pfet_03v3_EQVFPB_0.G1_0.n0 x1.xamp.pfet_03v3_EQVFPB_0.G1_0.n1 1.75936
R1771 x1.xamp.pfet_03v3_EQVFPB_0.G1_0.n54 x1.xamp.pfet_03v3_EQVFPB_0.G1_0.n1 1.74393
R1772 x1.xamp.pfet_03v3_EQVFPB_0.G1_0.n19 x1.xamp.pfet_03v3_EQVFPB_0.G1_0 1.7274
R1773 x1.xamp.pfet_03v3_EQVFPB_0.G1_0.n42 x1.xamp.pfet_03v3_EQVFPB_0.G1_0.n25 1.67514
R1774 x1.xamp.pfet_03v3_EQVFPB_0.G1_0.n46 x1.xamp.pfet_03v3_EQVFPB_0.G1_0.n24 1.67514
R1775 x1.xamp.pfet_03v3_EQVFPB_0.G1_0.n46 x1.xamp.pfet_03v3_EQVFPB_0.G1_0.n25 1.67514
R1776 x1.xamp.pfet_03v3_EQVFPB_0.G1_0.n50 x1.xamp.pfet_03v3_EQVFPB_0.G1_0.n27 1.67514
R1777 x1.xamp.pfet_03v3_EQVFPB_0.G1_0.n44 x1.xamp.pfet_03v3_EQVFPB_0.G1_0.n28 1.67514
R1778 x1.xamp.pfet_03v3_EQVFPB_0.G1_0.n40 x1.xamp.pfet_03v3_EQVFPB_0.G1_0.n39 1.67514
R1779 x1.xamp.pfet_03v3_EQVFPB_0.G1_0.n40 x1.xamp.pfet_03v3_EQVFPB_0.G1_0.n28 1.67514
R1780 x1.xamp.pfet_03v3_EQVFPB_0.G1_0.n44 x1.xamp.pfet_03v3_EQVFPB_0.G1_0.n27 1.67514
R1781 x1.xamp.pfet_03v3_EQVFPB_0.G1_0.n31 x1.xamp.pfet_03v3_EQVFPB_0.G1_0.t24 1.59325
R1782 x1.xamp.pfet_03v3_EQVFPB_0.G1_0.n33 x1.xamp.pfet_03v3_EQVFPB_0.G1_0.t28 1.59325
R1783 x1.xamp.pfet_03v3_EQVFPB_0.G1_0.n36 x1.xamp.pfet_03v3_EQVFPB_0.G1_0.t32 1.59325
R1784 x1.xamp.pfet_03v3_EQVFPB_0.G1_0.n34 x1.xamp.pfet_03v3_EQVFPB_0.G1_0.t36 1.59325
R1785 x1.xamp.pfet_03v3_EQVFPB_0.G1_0.n30 x1.xamp.pfet_03v3_EQVFPB_0.G1_0.t26 1.59325
R1786 x1.xamp.pfet_03v3_EQVFPB_0.G1_0.n32 x1.xamp.pfet_03v3_EQVFPB_0.G1_0.t30 1.59325
R1787 x1.xamp.pfet_03v3_EQVFPB_0.G1_0.n37 x1.xamp.pfet_03v3_EQVFPB_0.G1_0.t34 1.59325
R1788 x1.xamp.pfet_03v3_EQVFPB_0.G1_0.n35 x1.xamp.pfet_03v3_EQVFPB_0.G1_0.t38 1.59325
R1789 x1.xamp.pfet_03v3_EQVFPB_0.G1_0 x1.xamp.pfet_03v3_EQVFPB_0.G1_0.t23 1.59056
R1790 x1.xamp.pfet_03v3_EQVFPB_0.G1_0.n29 x1.xamp.pfet_03v3_EQVFPB_0.G1_0.n8 1.53701
R1791 x1.xamp.pfet_03v3_EQVFPB_0.G1_0.n53 x1.xamp.pfet_03v3_EQVFPB_0.G1_0 1.5005
R1792 x1.xamp.pfet_03v3_EQVFPB_0.G1_0.n29 x1.xamp.pfet_03v3_EQVFPB_0.G1_0 1.5005
R1793 x1.xamp.pfet_03v3_EQVFPB_0.G1_0.n48 x1.xamp.pfet_03v3_EQVFPB_0.G1_0 1.5005
R1794 x1.xamp.pfet_03v3_EQVFPB_0.G1_0.n11 x1.xamp.pfet_03v3_EQVFPB_0.G1_0 1.5005
R1795 x1.xamp.pfet_03v3_EQVFPB_0.G1_0.n7 x1.xamp.pfet_03v3_EQVFPB_0.G1_0 1.5005
R1796 x1.xamp.pfet_03v3_EQVFPB_0.G1_0.n13 x1.xamp.pfet_03v3_EQVFPB_0.G1_0 1.5005
R1797 x1.xamp.pfet_03v3_EQVFPB_0.G1_0.n2 x1.xamp.pfet_03v3_EQVFPB_0.G1_0 1.5005
R1798 x1.xamp.pfet_03v3_EQVFPB_0.G1_0.n15 x1.xamp.pfet_03v3_EQVFPB_0.G1_0 1.5005
R1799 x1.xamp.pfet_03v3_EQVFPB_0.G1_0.n11 x1.xamp.pfet_03v3_EQVFPB_0.G1_0.n10 1.48748
R1800 x1.xamp.pfet_03v3_EQVFPB_0.G1_0.n49 x1.xamp.pfet_03v3_EQVFPB_0.G1_0.n48 1.45191
R1801 x1.xamp.pfet_03v3_EQVFPB_0.G1_0.n13 x1.xamp.pfet_03v3_EQVFPB_0.G1_0.n12 1.44659
R1802 x1.xamp.pfet_03v3_EQVFPB_0.G1_0.n38 x1.xamp.pfet_03v3_EQVFPB_0.G1_0.n15 1.42275
R1803 x1.xamp.pfet_03v3_EQVFPB_0.G1_0.n51 x1.xamp.pfet_03v3_EQVFPB_0.G1_0.n50 1.42121
R1804 x1.xamp.pfet_03v3_EQVFPB_0.G1_0.n45 x1.xamp.pfet_03v3_EQVFPB_0.G1_0.n7 1.41261
R1805 x1.xamp.pfet_03v3_EQVFPB_0.G1_0.n15 x1.xamp.pfet_03v3_EQVFPB_0.G1_0.n14 1.40516
R1806 x1.xamp.pfet_03v3_EQVFPB_0.G1_0.n43 x1.xamp.pfet_03v3_EQVFPB_0.G1_0.n13 1.38092
R1807 x1.xamp.pfet_03v3_EQVFPB_0.G1_0.n41 x1.xamp.pfet_03v3_EQVFPB_0.G1_0.n2 1.37205
R1808 x1.xamp.pfet_03v3_EQVFPB_0.G1_0.n11 x1.xamp.pfet_03v3_EQVFPB_0.G1_0.n47 1.34289
R1809 x1.xamp.pfet_03v3_EQVFPB_0.G1_0.n29 x1.xamp.pfet_03v3_EQVFPB_0.G1_0.n52 1.27798
R1810 x1.xamp.pfet_03v3_EQVFPB_0.G1_0.n17 x1.xamp.pfet_03v3_EQVFPB_0.G1_0.n16 1.21495
R1811 x1.xamp.pfet_03v3_EQVFPB_0.G1_0.n19 x1.xamp.pfet_03v3_EQVFPB_0.G1_0.n18 1.17438
R1812 x1.xamp.pfet_03v3_EQVFPB_0.G1_0.n21 x1.xamp.pfet_03v3_EQVFPB_0.G1_0.n20 1.11532
R1813 x1.xamp.pfet_03v3_EQVFPB_0.G1_0.n23 x1.xamp.pfet_03v3_EQVFPB_0.G1_0.n22 1.09254
R1814 x1.xamp.pfet_03v3_EQVFPB_0.G1_0.n31 x1.xamp.pfet_03v3_EQVFPB_0.G1_0 1.06688
R1815 x1.xamp.pfet_03v3_EQVFPB_0.G1_0.n33 x1.xamp.pfet_03v3_EQVFPB_0.G1_0 1.06688
R1816 x1.xamp.pfet_03v3_EQVFPB_0.G1_0.n36 x1.xamp.pfet_03v3_EQVFPB_0.G1_0 1.06688
R1817 x1.xamp.pfet_03v3_EQVFPB_0.G1_0.n34 x1.xamp.pfet_03v3_EQVFPB_0.G1_0 1.06688
R1818 x1.xamp.pfet_03v3_EQVFPB_0.G1_0.n30 x1.xamp.pfet_03v3_EQVFPB_0.G1_0 1.06688
R1819 x1.xamp.pfet_03v3_EQVFPB_0.G1_0.n32 x1.xamp.pfet_03v3_EQVFPB_0.G1_0 1.06688
R1820 x1.xamp.pfet_03v3_EQVFPB_0.G1_0.n37 x1.xamp.pfet_03v3_EQVFPB_0.G1_0 1.06688
R1821 x1.xamp.pfet_03v3_EQVFPB_0.G1_0.n35 x1.xamp.pfet_03v3_EQVFPB_0.G1_0 1.06688
R1822 x1.nfet_03v3_EV2W8D_0.S1 x1.nfet_03v3_EV2W8D_0.S1.t26 21.0657
R1823 x1.nfet_03v3_EV2W8D_0.S1 x1.nfet_03v3_EV2W8D_0.S1.t29 21.0657
R1824 x1.nfet_03v3_EV2W8D_0.S1 x1.nfet_03v3_EV2W8D_0.S1.t27 21.0629
R1825 x1.nfet_03v3_EV2W8D_0.S1 x1.nfet_03v3_EV2W8D_0.S1.t28 21.0629
R1826 x1.nfet_03v3_EV2W8D_0.S1.n53 x1.nfet_03v3_EV2W8D_0.S1 13.8937
R1827 x1.nfet_03v3_EV2W8D_0.S1.n5 x1.nfet_03v3_EV2W8D_0.S1 6.83927
R1828 x1.nfet_03v3_EV2W8D_0.S1.n9 x1.nfet_03v3_EV2W8D_0.S1 6.83927
R1829 x1.nfet_03v3_EV2W8D_0.S1.n13 x1.nfet_03v3_EV2W8D_0.S1 6.83927
R1830 x1.nfet_03v3_EV2W8D_0.S1.n4 x1.nfet_03v3_EV2W8D_0.S1 6.81954
R1831 x1.nfet_03v3_EV2W8D_0.S1.n7 x1.nfet_03v3_EV2W8D_0.S1 6.81954
R1832 x1.nfet_03v3_EV2W8D_0.S1.n11 x1.nfet_03v3_EV2W8D_0.S1 6.81954
R1833 x1.nfet_03v3_EV2W8D_0.S1.n0 x1.nfet_03v3_EV2W8D_0.S1 6.81954
R1834 x1.nfet_03v3_EV2W8D_0.S1.n29 x1.nfet_03v3_EV2W8D_0.S1 6.5591
R1835 x1.nfet_03v3_EV2W8D_0.S1.n49 x1.nfet_03v3_EV2W8D_0.S1.n48 6.17514
R1836 x1.nfet_03v3_EV2W8D_0.S1.n19 x1.nfet_03v3_EV2W8D_0.S1 6.08461
R1837 x1.nfet_03v3_EV2W8D_0.S1.n22 x1.nfet_03v3_EV2W8D_0.S1 6.08461
R1838 x1.nfet_03v3_EV2W8D_0.S1.n25 x1.nfet_03v3_EV2W8D_0.S1 6.08461
R1839 x1.nfet_03v3_EV2W8D_0.S1.n26 x1.nfet_03v3_EV2W8D_0.S1 6.08461
R1840 x1.nfet_03v3_EV2W8D_0.S1.n27 x1.nfet_03v3_EV2W8D_0.S1 6.08461
R1841 x1.nfet_03v3_EV2W8D_0.S1.n52 x1.nfet_03v3_EV2W8D_0.S1 6.08067
R1842 x1.nfet_03v3_EV2W8D_0.S1.n16 x1.nfet_03v3_EV2W8D_0.S1 6.08067
R1843 x1.nfet_03v3_EV2W8D_0.S1.n24 x1.nfet_03v3_EV2W8D_0.S1 6.08067
R1844 x1.nfet_03v3_EV2W8D_0.S1.n49 x1.nfet_03v3_EV2W8D_0.S1.n4 5.54425
R1845 x1.nfet_03v3_EV2W8D_0.S1.n31 x1.nfet_03v3_EV2W8D_0.S1.n1 5.46207
R1846 x1.nfet_03v3_EV2W8D_0.S1.n53 x1.nfet_03v3_EV2W8D_0.S1.n52 5.45498
R1847 x1.nfet_03v3_EV2W8D_0.S1.n47 x1.nfet_03v3_EV2W8D_0.S1.n46 5.0605
R1848 x1.nfet_03v3_EV2W8D_0.S1.n45 x1.nfet_03v3_EV2W8D_0.S1.n44 5.0605
R1849 x1.nfet_03v3_EV2W8D_0.S1.n41 x1.nfet_03v3_EV2W8D_0.S1.n40 5.0605
R1850 x1.nfet_03v3_EV2W8D_0.S1.n39 x1.nfet_03v3_EV2W8D_0.S1.n38 5.0605
R1851 x1.nfet_03v3_EV2W8D_0.S1.n35 x1.nfet_03v3_EV2W8D_0.S1.n34 5.0605
R1852 x1.nfet_03v3_EV2W8D_0.S1.n33 x1.nfet_03v3_EV2W8D_0.S1.n32 5.0605
R1853 x1.nfet_03v3_EV2W8D_0.S1.n1 x1.nfet_03v3_EV2W8D_0.S1.n0 4.97461
R1854 x1.nfet_03v3_EV2W8D_0.S1 x1.nfet_03v3_EV2W8D_0.S1.t24 4.7885
R1855 x1.nfet_03v3_EV2W8D_0.S1 x1.nfet_03v3_EV2W8D_0.S1.t7 4.62903
R1856 x1.nfet_03v3_EV2W8D_0.S1 x1.nfet_03v3_EV2W8D_0.S1.t5 4.62903
R1857 x1.nfet_03v3_EV2W8D_0.S1 x1.nfet_03v3_EV2W8D_0.S1.t3 4.62903
R1858 x1.nfet_03v3_EV2W8D_0.S1 x1.nfet_03v3_EV2W8D_0.S1.t1 4.62903
R1859 x1.nfet_03v3_EV2W8D_0.S1 x1.nfet_03v3_EV2W8D_0.S1.t6 4.62903
R1860 x1.nfet_03v3_EV2W8D_0.S1 x1.nfet_03v3_EV2W8D_0.S1.t4 4.62903
R1861 x1.nfet_03v3_EV2W8D_0.S1 x1.nfet_03v3_EV2W8D_0.S1.t2 4.62903
R1862 x1.nfet_03v3_EV2W8D_0.S1 x1.nfet_03v3_EV2W8D_0.S1.t0 4.62903
R1863 x1.nfet_03v3_EV2W8D_0.S1.n51 x1.nfet_03v3_EV2W8D_0.S1.n50 4.56675
R1864 x1.nfet_03v3_EV2W8D_0.S1.n17 x1.nfet_03v3_EV2W8D_0.S1.n8 4.56675
R1865 x1.nfet_03v3_EV2W8D_0.S1.n18 x1.nfet_03v3_EV2W8D_0.S1.n10 4.56675
R1866 x1.nfet_03v3_EV2W8D_0.S1.n20 x1.nfet_03v3_EV2W8D_0.S1.n12 4.56675
R1867 x1.nfet_03v3_EV2W8D_0.S1.n21 x1.nfet_03v3_EV2W8D_0.S1.n14 4.56675
R1868 x1.nfet_03v3_EV2W8D_0.S1.n23 x1.nfet_03v3_EV2W8D_0.S1.n15 4.56496
R1869 x1.nfet_03v3_EV2W8D_0.S1.n6 x1.nfet_03v3_EV2W8D_0.S1.n3 4.56367
R1870 x1.nfet_03v3_EV2W8D_0.S1.n32 x1.nfet_03v3_EV2W8D_0.S1.n31 4.5005
R1871 x1.nfet_03v3_EV2W8D_0.S1.n36 x1.nfet_03v3_EV2W8D_0.S1.n35 4.5005
R1872 x1.nfet_03v3_EV2W8D_0.S1.n38 x1.nfet_03v3_EV2W8D_0.S1.n37 4.5005
R1873 x1.nfet_03v3_EV2W8D_0.S1.n42 x1.nfet_03v3_EV2W8D_0.S1.n41 4.5005
R1874 x1.nfet_03v3_EV2W8D_0.S1.n44 x1.nfet_03v3_EV2W8D_0.S1.n43 4.5005
R1875 x1.nfet_03v3_EV2W8D_0.S1.n48 x1.nfet_03v3_EV2W8D_0.S1.n47 4.5005
R1876 x1.nfet_03v3_EV2W8D_0.S1.n2 x1.nfet_03v3_EV2W8D_0.S1.n27 4.34158
R1877 x1.nfet_03v3_EV2W8D_0.S1.n30 x1.nfet_03v3_EV2W8D_0.S1.n29 3.64035
R1878 x1.nfet_03v3_EV2W8D_0.S1.n2 x1.nfet_03v3_EV2W8D_0.S1.n1 1.11956
R1879 x1.nfet_03v3_EV2W8D_0.S1.n29 x1.nfet_03v3_EV2W8D_0.S1.n28 2.2505
R1880 x1.nfet_03v3_EV2W8D_0.S1 x1.nfet_03v3_EV2W8D_0.S1.t22 2.25015
R1881 x1.nfet_03v3_EV2W8D_0.S1 x1.nfet_03v3_EV2W8D_0.S1.t20 2.25015
R1882 x1.nfet_03v3_EV2W8D_0.S1 x1.nfet_03v3_EV2W8D_0.S1.t18 2.25015
R1883 x1.nfet_03v3_EV2W8D_0.S1 x1.nfet_03v3_EV2W8D_0.S1.t17 2.25015
R1884 x1.nfet_03v3_EV2W8D_0.S1 x1.nfet_03v3_EV2W8D_0.S1.t15 2.25015
R1885 x1.nfet_03v3_EV2W8D_0.S1 x1.nfet_03v3_EV2W8D_0.S1.t14 2.25015
R1886 x1.nfet_03v3_EV2W8D_0.S1 x1.nfet_03v3_EV2W8D_0.S1.t12 2.25015
R1887 x1.nfet_03v3_EV2W8D_0.S1 x1.nfet_03v3_EV2W8D_0.S1.t21 2.25015
R1888 x1.nfet_03v3_EV2W8D_0.S1 x1.nfet_03v3_EV2W8D_0.S1.t19 2.25015
R1889 x1.nfet_03v3_EV2W8D_0.S1 x1.nfet_03v3_EV2W8D_0.S1.t16 2.25015
R1890 x1.nfet_03v3_EV2W8D_0.S1 x1.nfet_03v3_EV2W8D_0.S1.t13 2.25015
R1891 x1.nfet_03v3_EV2W8D_0.S1 x1.nfet_03v3_EV2W8D_0.S1.t11 2.25015
R1892 x1.nfet_03v3_EV2W8D_0.S1 x1.nfet_03v3_EV2W8D_0.S1.t10 2.25015
R1893 x1.nfet_03v3_EV2W8D_0.S1 x1.nfet_03v3_EV2W8D_0.S1.t9 2.25015
R1894 x1.nfet_03v3_EV2W8D_0.S1 x1.nfet_03v3_EV2W8D_0.S1.t8 2.25015
R1895 x1.nfet_03v3_EV2W8D_0.S1.n35 x1.nfet_03v3_EV2W8D_0.S1.n14 2.20425
R1896 x1.nfet_03v3_EV2W8D_0.S1.n41 x1.nfet_03v3_EV2W8D_0.S1.n10 2.1655
R1897 x1.nfet_03v3_EV2W8D_0.S1.n47 x1.nfet_03v3_EV2W8D_0.S1.n6 2.12425
R1898 x1.nfet_03v3_EV2W8D_0.S1.n32 x1.nfet_03v3_EV2W8D_0.S1.n15 1.70563
R1899 x1.nfet_03v3_EV2W8D_0.S1.n46 x1.nfet_03v3_EV2W8D_0.S1.n45 1.67514
R1900 x1.nfet_03v3_EV2W8D_0.S1.n40 x1.nfet_03v3_EV2W8D_0.S1.n39 1.67514
R1901 x1.nfet_03v3_EV2W8D_0.S1.n34 x1.nfet_03v3_EV2W8D_0.S1.n33 1.67514
R1902 x1.nfet_03v3_EV2W8D_0.S1.n43 x1.nfet_03v3_EV2W8D_0.S1.n42 1.67514
R1903 x1.nfet_03v3_EV2W8D_0.S1.n37 x1.nfet_03v3_EV2W8D_0.S1.n36 1.67514
R1904 x1.nfet_03v3_EV2W8D_0.S1.n38 x1.nfet_03v3_EV2W8D_0.S1.n12 1.6655
R1905 x1.nfet_03v3_EV2W8D_0.S1.n44 x1.nfet_03v3_EV2W8D_0.S1.n8 1.623
R1906 x1.nfet_03v3_EV2W8D_0.S1 x1.nfet_03v3_EV2W8D_0.S1.n55 1.59056
R1907 x1.nfet_03v3_EV2W8D_0.S1.n50 x1.nfet_03v3_EV2W8D_0.S1.n49 1.5805
R1908 x1.nfet_03v3_EV2W8D_0.S1 x1.nfet_03v3_EV2W8D_0.S1.n53 1.5005
R1909 x1.nfet_03v3_EV2W8D_0.S1.n50 x1.nfet_03v3_EV2W8D_0.S1 1.5005
R1910 x1.nfet_03v3_EV2W8D_0.S1.n6 x1.nfet_03v3_EV2W8D_0.S1 1.5005
R1911 x1.nfet_03v3_EV2W8D_0.S1.n8 x1.nfet_03v3_EV2W8D_0.S1 1.5005
R1912 x1.nfet_03v3_EV2W8D_0.S1.n10 x1.nfet_03v3_EV2W8D_0.S1 1.5005
R1913 x1.nfet_03v3_EV2W8D_0.S1.n12 x1.nfet_03v3_EV2W8D_0.S1 1.5005
R1914 x1.nfet_03v3_EV2W8D_0.S1.n14 x1.nfet_03v3_EV2W8D_0.S1 1.5005
R1915 x1.nfet_03v3_EV2W8D_0.S1.n15 x1.nfet_03v3_EV2W8D_0.S1 1.5005
R1916 x1.nfet_03v3_EV2W8D_0.S1.n43 x1.nfet_03v3_EV2W8D_0.S1.n5 1.19943
R1917 x1.nfet_03v3_EV2W8D_0.S1.n37 x1.nfet_03v3_EV2W8D_0.S1.n9 1.19943
R1918 x1.nfet_03v3_EV2W8D_0.S1.n31 x1.nfet_03v3_EV2W8D_0.S1.n13 1.19943
R1919 x1.nfet_03v3_EV2W8D_0.S1.n46 x1.nfet_03v3_EV2W8D_0.S1.n4 1.19139
R1920 x1.nfet_03v3_EV2W8D_0.S1.n40 x1.nfet_03v3_EV2W8D_0.S1.n7 1.19139
R1921 x1.nfet_03v3_EV2W8D_0.S1.n34 x1.nfet_03v3_EV2W8D_0.S1.n11 1.19139
R1922 x1.nfet_03v3_EV2W8D_0.S1.n30 x1.nfet_03v3_EV2W8D_0.S1.t25 1.1035
R1923 x1.nfet_03v3_EV2W8D_0.S1.n24 x1.nfet_03v3_EV2W8D_0.S1.n23 0.895357
R1924 x1.nfet_03v3_EV2W8D_0.S1.n51 x1.nfet_03v3_EV2W8D_0.S1.n3 0.887643
R1925 x1.nfet_03v3_EV2W8D_0.S1.n27 x1.nfet_03v3_EV2W8D_0.S1.n26 0.8825
R1926 x1.nfet_03v3_EV2W8D_0.S1.n52 x1.nfet_03v3_EV2W8D_0.S1.n51 0.879929
R1927 x1.nfet_03v3_EV2W8D_0.S1.n18 x1.nfet_03v3_EV2W8D_0.S1.n17 0.879929
R1928 x1.nfet_03v3_EV2W8D_0.S1.n19 x1.nfet_03v3_EV2W8D_0.S1.n18 0.879929
R1929 x1.nfet_03v3_EV2W8D_0.S1.n20 x1.nfet_03v3_EV2W8D_0.S1.n19 0.879929
R1930 x1.nfet_03v3_EV2W8D_0.S1.n21 x1.nfet_03v3_EV2W8D_0.S1.n20 0.879929
R1931 x1.nfet_03v3_EV2W8D_0.S1.n22 x1.nfet_03v3_EV2W8D_0.S1.n21 0.879929
R1932 x1.nfet_03v3_EV2W8D_0.S1.n26 x1.nfet_03v3_EV2W8D_0.S1.n25 0.879929
R1933 x1.nfet_03v3_EV2W8D_0.S1.n16 x1.nfet_03v3_EV2W8D_0.S1.n3 0.872214
R1934 x1.nfet_03v3_EV2W8D_0.S1.n17 x1.nfet_03v3_EV2W8D_0.S1.n16 0.872214
R1935 x1.nfet_03v3_EV2W8D_0.S1.n23 x1.nfet_03v3_EV2W8D_0.S1.n22 0.872214
R1936 x1.nfet_03v3_EV2W8D_0.S1.n25 x1.nfet_03v3_EV2W8D_0.S1.n24 0.872214
R1937 x1.nfet_03v3_EV2W8D_0.S1.n55 x1.nfet_03v3_EV2W8D_0.S1.n54 0.8405
R1938 x1.nfet_03v3_EV2W8D_0.S1.n55 x1.nfet_03v3_EV2W8D_0.S1.t23 0.660099
R1939 x1.nfet_03v3_EV2W8D_0.S1.n45 x1.nfet_03v3_EV2W8D_0.S1.n7 0.48425
R1940 x1.nfet_03v3_EV2W8D_0.S1.n39 x1.nfet_03v3_EV2W8D_0.S1.n11 0.48425
R1941 x1.nfet_03v3_EV2W8D_0.S1.n33 x1.nfet_03v3_EV2W8D_0.S1.n0 0.48425
R1942 x1.nfet_03v3_EV2W8D_0.S1.n48 x1.nfet_03v3_EV2W8D_0.S1.n5 0.476214
R1943 x1.nfet_03v3_EV2W8D_0.S1.n42 x1.nfet_03v3_EV2W8D_0.S1.n9 0.476214
R1944 x1.nfet_03v3_EV2W8D_0.S1.n36 x1.nfet_03v3_EV2W8D_0.S1.n13 0.476214
R1945 x1.nfet_03v3_EV2W8D_0.S1.n28 x1.nfet_03v3_EV2W8D_0.S1 0.308577
R1946 x1.nfet_03v3_EV2W8D_0.S1.n28 x1.nfet_03v3_EV2W8D_0.S1 0.284346
R1947 x1.nfet_03v3_EV2W8D_0.S1.n2 x1.nfet_03v3_EV2W8D_0.S1.n30 5.71223
R1948 x1.pnp_05p00x05p00_0_0[0|0].E.t22 x1.pnp_05p00x05p00_0_0[0|0].E.n12 59.7158
R1949 x1.pnp_05p00x05p00_0_0[0|0].E x1.pnp_05p00x05p00_0_0[0|0].E.t22 54.6684
R1950 x1.pnp_05p00x05p00_0_0[0|0].E.t24 x1.pnp_05p00x05p00_0_0[0|0].E.t23 17.3045
R1951 x1.pnp_05p00x05p00_0_0[0|0].E.n0 x1.pnp_05p00x05p00_0_0[0|0].E.t9 6.60638
R1952 x1.pnp_05p00x05p00_0_0[0|0].E.n0 x1.pnp_05p00x05p00_0_0[0|0].E.t6 6.60638
R1953 x1.pnp_05p00x05p00_0_0[0|0].E.n0 x1.pnp_05p00x05p00_0_0[0|0].E.t5 6.4095
R1954 x1.pnp_05p00x05p00_0_0[0|0].E.n0 x1.pnp_05p00x05p00_0_0[0|0].E.t32 6.4095
R1955 x1.pnp_05p00x05p00_0_0[0|0].E.n0 x1.pnp_05p00x05p00_0_0[0|0].E.t7 6.4095
R1956 x1.pnp_05p00x05p00_0_0[0|0].E.n0 x1.pnp_05p00x05p00_0_0[0|0].E.t8 6.4095
R1957 x1.pnp_05p00x05p00_0_0[0|0].E.n30 x1.pnp_05p00x05p00_0_0[0|0].E 5.05096
R1958 x1.pnp_05p00x05p00_0_0[0|0].E.n13 x1.pnp_05p00x05p00_0_0[0|0].E 4.96686
R1959 x1.pnp_05p00x05p00_0_0[0|0].E.t24 x1.pnp_05p00x05p00_0_0[0|0].E.n41 4.3685
R1960 x1.pnp_05p00x05p00_0_0[0|0].E.n16 x1.pnp_05p00x05p00_0_0[0|0].E 3.76392
R1961 x1.pnp_05p00x05p00_0_0[0|0].E.n20 x1.pnp_05p00x05p00_0_0[0|0].E 3.76392
R1962 x1.pnp_05p00x05p00_0_0[0|0].E.n13 x1.pnp_05p00x05p00_0_0[0|0].E 3.758
R1963 x1.pnp_05p00x05p00_0_0[0|0].E.n14 x1.pnp_05p00x05p00_0_0[0|0].E 3.758
R1964 x1.pnp_05p00x05p00_0_0[0|0].E.n15 x1.pnp_05p00x05p00_0_0[0|0].E 3.758
R1965 x1.pnp_05p00x05p00_0_0[0|0].E.n17 x1.pnp_05p00x05p00_0_0[0|0].E 3.758
R1966 x1.pnp_05p00x05p00_0_0[0|0].E.n18 x1.pnp_05p00x05p00_0_0[0|0].E 3.758
R1967 x1.pnp_05p00x05p00_0_0[0|0].E.n19 x1.pnp_05p00x05p00_0_0[0|0].E 3.758
R1968 x1.pnp_05p00x05p00_0_0[0|0].E.n21 x1.pnp_05p00x05p00_0_0[0|0].E 3.758
R1969 x1.pnp_05p00x05p00_0_0[0|0].E.n22 x1.pnp_05p00x05p00_0_0[0|0].E 3.758
R1970 x1.pnp_05p00x05p00_0_0[0|0].E.n23 x1.pnp_05p00x05p00_0_0[0|0].E 3.758
R1971 x1.pnp_05p00x05p00_0_0[0|0].E.n24 x1.pnp_05p00x05p00_0_0[0|0].E 3.758
R1972 x1.pnp_05p00x05p00_0_0[0|0].E.n25 x1.pnp_05p00x05p00_0_0[0|0].E 3.758
R1973 x1.pnp_05p00x05p00_0_0[0|0].E.n26 x1.pnp_05p00x05p00_0_0[0|0].E 3.758
R1974 x1.pnp_05p00x05p00_0_0[0|0].E.n27 x1.pnp_05p00x05p00_0_0[0|0].E 3.758
R1975 x1.pnp_05p00x05p00_0_0[0|0].E.n28 x1.pnp_05p00x05p00_0_0[0|0].E 3.758
R1976 x1.pnp_05p00x05p00_0_0[0|0].E.n0 x1.pnp_05p00x05p00_0_0[0|0].E.n39 2.77855
R1977 x1.pnp_05p00x05p00_0_0[0|0].E.n30 x1.pnp_05p00x05p00_0_0[0|0].E.n29 2.61664
R1978 x1.pnp_05p00x05p00_0_0[0|0].E.n5 x1.pnp_05p00x05p00_0_0[0|0].E.n3 2.55731
R1979 x1.pnp_05p00x05p00_0_0[0|0].E.n40 x1.pnp_05p00x05p00_0_0[0|0].E.n0 2.40658
R1980 x1.pnp_05p00x05p00_0_0[0|0].E.t23 x1.pnp_05p00x05p00_0_0[0|0].E 2.33592
R1981 x1.pnp_05p00x05p00_0_0[0|0].E x1.pnp_05p00x05p00_0_0[0|0].E.t27 2.33408
R1982 x1.pnp_05p00x05p00_0_0[0|0].E x1.pnp_05p00x05p00_0_0[0|0].E.t26 2.33408
R1983 x1.pnp_05p00x05p00_0_0[0|0].E x1.pnp_05p00x05p00_0_0[0|0].E.t29 2.33408
R1984 x1.pnp_05p00x05p00_0_0[0|0].E x1.pnp_05p00x05p00_0_0[0|0].E.t28 2.33408
R1985 x1.pnp_05p00x05p00_0_0[0|0].E x1.pnp_05p00x05p00_0_0[0|0].E.t4 2.33408
R1986 x1.pnp_05p00x05p00_0_0[0|0].E x1.pnp_05p00x05p00_0_0[0|0].E.t3 2.33408
R1987 x1.pnp_05p00x05p00_0_0[0|0].E x1.pnp_05p00x05p00_0_0[0|0].E.t2 2.33408
R1988 x1.pnp_05p00x05p00_0_0[0|0].E x1.pnp_05p00x05p00_0_0[0|0].E.t1 2.33408
R1989 x1.pnp_05p00x05p00_0_0[0|0].E x1.pnp_05p00x05p00_0_0[0|0].E.t0 2.33408
R1990 x1.pnp_05p00x05p00_0_0[0|0].E x1.pnp_05p00x05p00_0_0[0|0].E.t20 2.33408
R1991 x1.pnp_05p00x05p00_0_0[0|0].E x1.pnp_05p00x05p00_0_0[0|0].E.t31 2.33408
R1992 x1.pnp_05p00x05p00_0_0[0|0].E x1.pnp_05p00x05p00_0_0[0|0].E.t30 2.33408
R1993 x1.pnp_05p00x05p00_0_0[0|0].E x1.pnp_05p00x05p00_0_0[0|0].E.t21 2.33408
R1994 x1.pnp_05p00x05p00_0_0[0|0].E x1.pnp_05p00x05p00_0_0[0|0].E.t11 2.33408
R1995 x1.pnp_05p00x05p00_0_0[0|0].E x1.pnp_05p00x05p00_0_0[0|0].E.t10 2.33408
R1996 x1.pnp_05p00x05p00_0_0[0|0].E x1.pnp_05p00x05p00_0_0[0|0].E.t25 2.33408
R1997 x1.pnp_05p00x05p00_0_0[0|0].E.n10 x1.pnp_05p00x05p00_0_0[0|0].E.n11 0.0546641
R1998 x1.pnp_05p00x05p00_0_0[0|0].E.n29 x1.pnp_05p00x05p00_0_0[0|0].E.n12 2.2505
R1999 x1.pnp_05p00x05p00_0_0[0|0].E.n36 x1.pnp_05p00x05p00_0_0[0|0].E.n35 2.2431
R2000 x1.pnp_05p00x05p00_0_0[0|0].E.n34 x1.pnp_05p00x05p00_0_0[0|0].E.n2 2.34882
R2001 x1.pnp_05p00x05p00_0_0[0|0].E x1.pnp_05p00x05p00_0_0[0|0].E.t24 1.78958
R2002 x1.pnp_05p00x05p00_0_0[0|0].E.n3 x1.pnp_05p00x05p00_0_0[0|0].E.n36 1.50444
R2003 x1.pnp_05p00x05p00_0_0[0|0].E.n6 x1.pnp_05p00x05p00_0_0[0|0].E.n5 0.0347093
R2004 x1.pnp_05p00x05p00_0_0[0|0].E.n39 x1.pnp_05p00x05p00_0_0[0|0].E.n8 1.46058
R2005 x1.pnp_05p00x05p00_0_0[0|0].E.n35 x1.pnp_05p00x05p00_0_0[0|0].E.n34 1.37639
R2006 x1.pnp_05p00x05p00_0_0[0|0].E.n37 x1.pnp_05p00x05p00_0_0[0|0].E.n33 1.35249
R2007 x1.pnp_05p00x05p00_0_0[0|0].E.n2 x1.pnp_05p00x05p00_0_0[0|0].E.n1 0.0344951
R2008 x1.pnp_05p00x05p00_0_0[0|0].E x1.pnp_05p00x05p00_0_0[0|0].E.n32 1.14639
R2009 x1.pnp_05p00x05p00_0_0[0|0].E x1.pnp_05p00x05p00_0_0[0|0].E.n40 1.14639
R2010 x1.pnp_05p00x05p00_0_0[0|0].E.n38 x1.pnp_05p00x05p00_0_0[0|0].E.n37 1.09113
R2011 x1.pnp_05p00x05p00_0_0[0|0].E.n8 x1.pnp_05p00x05p00_0_0[0|0].E.n9 1.09054
R2012 x1.pnp_05p00x05p00_0_0[0|0].E.n9 x1.pnp_05p00x05p00_0_0[0|0].E.n10 1.09054
R2013 x1.pnp_05p00x05p00_0_0[0|0].E.n1 x1.pnp_05p00x05p00_0_0[0|0].E.n7 1.09054
R2014 x1.pnp_05p00x05p00_0_0[0|0].E.n7 x1.pnp_05p00x05p00_0_0[0|0].E.n6 1.09054
R2015 x1.pnp_05p00x05p00_0_0[0|0].E.n39 x1.pnp_05p00x05p00_0_0[0|0].E.n33 0.673272
R2016 x1.pnp_05p00x05p00_0_0[0|0].E.n11 x1.pnp_05p00x05p00_0_0[0|0].E.n3 1.49414
R2017 x1.pnp_05p00x05p00_0_0[0|0].E.n28 x1.pnp_05p00x05p00_0_0[0|0].E.n27 0.581409
R2018 x1.pnp_05p00x05p00_0_0[0|0].E.n27 x1.pnp_05p00x05p00_0_0[0|0].E.n26 0.581409
R2019 x1.pnp_05p00x05p00_0_0[0|0].E.n26 x1.pnp_05p00x05p00_0_0[0|0].E.n25 0.581409
R2020 x1.pnp_05p00x05p00_0_0[0|0].E.n25 x1.pnp_05p00x05p00_0_0[0|0].E.n24 0.581409
R2021 x1.pnp_05p00x05p00_0_0[0|0].E.n24 x1.pnp_05p00x05p00_0_0[0|0].E.n23 0.581409
R2022 x1.pnp_05p00x05p00_0_0[0|0].E.n23 x1.pnp_05p00x05p00_0_0[0|0].E.n22 0.581409
R2023 x1.pnp_05p00x05p00_0_0[0|0].E.n22 x1.pnp_05p00x05p00_0_0[0|0].E.n21 0.581409
R2024 x1.pnp_05p00x05p00_0_0[0|0].E.n21 x1.pnp_05p00x05p00_0_0[0|0].E.n20 0.581409
R2025 x1.pnp_05p00x05p00_0_0[0|0].E.n20 x1.pnp_05p00x05p00_0_0[0|0].E.n19 0.581409
R2026 x1.pnp_05p00x05p00_0_0[0|0].E.n19 x1.pnp_05p00x05p00_0_0[0|0].E.n18 0.581409
R2027 x1.pnp_05p00x05p00_0_0[0|0].E.n18 x1.pnp_05p00x05p00_0_0[0|0].E.n17 0.581409
R2028 x1.pnp_05p00x05p00_0_0[0|0].E.n17 x1.pnp_05p00x05p00_0_0[0|0].E.n16 0.581409
R2029 x1.pnp_05p00x05p00_0_0[0|0].E.n16 x1.pnp_05p00x05p00_0_0[0|0].E.n15 0.581409
R2030 x1.pnp_05p00x05p00_0_0[0|0].E.n15 x1.pnp_05p00x05p00_0_0[0|0].E.n14 0.581409
R2031 x1.pnp_05p00x05p00_0_0[0|0].E.n14 x1.pnp_05p00x05p00_0_0[0|0].E.n13 0.581409
R2032 x1.pnp_05p00x05p00_0_0[0|0].E.n34 x1.pnp_05p00x05p00_0_0[0|0].E.n33 0.562777
R2033 x1.pnp_05p00x05p00_0_0[0|0].E.n29 x1.pnp_05p00x05p00_0_0[0|0].E.n28 0.377545
R2034 x1.pnp_05p00x05p00_0_0[0|0].E.n35 x1.pnp_05p00x05p00_0_0[0|0].E 0.346407
R2035 x1.pnp_05p00x05p00_0_0[0|0].E.n36 x1.pnp_05p00x05p00_0_0[0|0].E 0.345687
R2036 x1.pnp_05p00x05p00_0_0[0|0].E.n32 x1.pnp_05p00x05p00_0_0[0|0].E.n31 0.324974
R2037 x1.pnp_05p00x05p00_0_0[0|0].E.n31 x1.pnp_05p00x05p00_0_0[0|0].E.n30 0.315995
R2038 x1.pnp_05p00x05p00_0_0[0|0].E.n1 x1.pnp_05p00x05p00_0_0[0|0].E 0.30148
R2039 x1.pnp_05p00x05p00_0_0[0|0].E.n8 x1.pnp_05p00x05p00_0_0[0|0].E 0.30148
R2040 x1.pnp_05p00x05p00_0_0[0|0].E.n7 x1.pnp_05p00x05p00_0_0[0|0].E 0.30112
R2041 x1.pnp_05p00x05p00_0_0[0|0].E.n9 x1.pnp_05p00x05p00_0_0[0|0].E 0.30112
R2042 x1.pnp_05p00x05p00_0_0[0|0].E.n6 x1.pnp_05p00x05p00_0_0[0|0].E 0.30076
R2043 x1.pnp_05p00x05p00_0_0[0|0].E.n10 x1.pnp_05p00x05p00_0_0[0|0].E 0.30076
R2044 x1.pnp_05p00x05p00_0_0[0|0].E.n31 x1.pnp_05p00x05p00_0_0[0|0].E.n12 0.216104
R2045 x1.pnp_05p00x05p00_0_0[0|0].E.n40 x1.pnp_05p00x05p00_0_0[0|0].E.n32 0.189974
R2046 x1.pnp_05p00x05p00_0_0[0|0].E.n38 x1.pnp_05p00x05p00_0_0[0|0].E.n11 1.12588
R2047 x1.pnp_05p00x05p00_0_0[0|0].E.n38 x1.pnp_05p00x05p00_0_0[0|0].E.n9 0.0905
R2048 x1.pnp_05p00x05p00_0_0[0|0].E.n37 x1.pnp_05p00x05p00_0_0[0|0].E.n8 0.0905
R2049 x1.pnp_05p00x05p00_0_0[0|0].E.n4 x1.pnp_05p00x05p00_0_0[0|0].E.n7 0.0905
R2050 x1.pnp_05p00x05p00_0_0[0|0].E.n5 x1.pnp_05p00x05p00_0_0[0|0].E.n4 1.14587
R2051 x1.pnp_05p00x05p00_0_0[0|0].E.n2 x1.pnp_05p00x05p00_0_0[0|0].E.n4 1.1459
C0 trim[1] trim[2] 0.02218f
C1 trim[13] a_n8227_n17722# 0.25701f
C2 x1.xamp.out1p x1.pnp_05p00x05p00_0_0[1|1].E 2.68137f
C3 x1.xtr.nfet_03v3_GP977X_0.S14 x1.pfet_03v3_BWTVHK_0.D 0.01904f
C4 ibias2_1u vbg 0.01429f
C5 x1.xtr.nfet_03v3_GP977X_0.S13 x1.xtr.nfet_03v3_GP977X_0.S14 0.14864f
C6 dvdd x1.gf180mcu_as_sc_mcu7t3v3__buff_2_7.Y 0.17179f
C7 dvdd x1.gf180mcu_as_sc_mcu7t3v3__buff_2_5.Y 0.16607f
C8 vbg gf180mcu_ocd_ip__classab_buffer_0.se_folded_cascode_np_ab_0.outb1n 12.5557f
C9 dvdd x1.vbg 9.05991f
C10 gf180mcu_ocd_ip__classab_buffer_0.se_folded_cascode_np_ab_0.pfet_03v3_XWLNX2_0.D gf180mcu_ocd_ip__classab_buffer_0.se_folded_cascode_np_ab_0.outa1p 4.06153f
C11 trim[8] trim[7] 0.01789f
C12 gf180mcu_ocd_ip__classab_buffer_0.se_folded_cascode_np_ab_0.nfet_03v3_XRMCLC_0.S0_0 gf180mcu_ocd_ip__classab_buffer_0.se_folded_cascode_np_ab_0.pfet_03v3_XWLNX2_0.D 4.67783f
C13 a_n8227_n15930# x1.gf180mcu_as_sc_mcu7t3v3__buff_2_15.Y 0.21413f
C14 gf180mcu_ocd_ip__classab_buffer_0.se_folded_cascode_np_ab_0.nfet_03v3_XHQ8ZW_0.S0_0 vbg 2.24283f
C15 x1.xtr.nfet_03v3_GP977X_0.S1 x1.xtr.nfet_03v3_GP977X_0.S2 0.14865f
C16 dvdd a_n8227_n23322# 0.35905f
C17 dvdd a_n8227_n25114# 0.36016f
C18 trim[13] x1.gf180mcu_as_sc_mcu7t3v3__buff_2_14.Y 0.02483f
C19 x1.vbg x1.nfet_03v3_EV2W8D_0.S1 2.06605f
C20 trim[12] x1.gf180mcu_as_sc_mcu7t3v3__buff_2_12.Y 0.03698f
C21 x1.pnp_05p00x05p00_0_0[0|0].E x1.gf180mcu_as_sc_mcu7t3v3__buff_2_9.Y 0.33846f
C22 x1.xtr.nfet_03v3_GP977X_0.S2 x1.gf180mcu_as_sc_mcu7t3v3__buff_2_13.Y 0.04037f
C23 trim[7] trim[6] 0.02221f
C24 x1.xtr.top x1.ena_buf 0.15438f
C25 trim[13] a_n8227_n16826# 0.01248f
C26 x1.xamp.vbn1 x1.xamp.pfet_03v3_EQVFPB_0.G1_0 0.03991f
C27 trim[3] a_n8227_n26906# 0.25473f
C28 x1.xamp.pfet_03v3_EQVFPB_0.S1_0 x1.xamp.pfet_03v3_EQVFPB_0.G1_0 7.76954f
C29 x1.xamp.vbn2 x1.xamp.out1p 5.86875f
C30 trim[12] a_n8227_n18618# 0.2568f
C31 dvdd x1.gf180mcu_as_sc_mcu7t3v3__buff_2_8.Y 0.1697f
C32 dvdd x1.xamp.pfet_03v3_EQVFPB_0.G1_0 26.662f
C33 trim[5] x1.gf180mcu_as_sc_mcu7t3v3__buff_2_6.Y 0.02404f
C34 gf180mcu_ocd_ip__classab_buffer_0.se_folded_cascode_np_ab_0.vbp1 gf180mcu_ocd_ip__classab_buffer_0.se_folded_cascode_np_ab_0.outa1p 0.23182f
C35 x1.xamp.pfet_03v3_EQVFPB_0.G1_0 x1.xamp.vbp1 0.04222f
C36 x1.vbg gf180mcu_ocd_ip__classab_buffer_0.se_folded_cascode_np_ab_0.pfet_03v3_XWLNX2_0.D 0.03824f
C37 trim[14] x1.gf180mcu_as_sc_mcu7t3v3__buff_2_14.Y 0.03679f
C38 dvdd trim[0] 0.31676f
C39 x1.pnp_05p00x05p00_0_0[0|0].E x1.xtr.nfet_03v3_GP977X_0.S9 0.16035f
C40 ibias1_250n x1.xamp.out1n 0.04799f
C41 dvdd ena 0.39698f
C42 x1.vbg x1.xtr.nfet_03v3_GP977X_0.S15 0.0173f
C43 x1.xamp.pfet_03v3_EQVFPB_0.G1_0 x1.nfet_03v3_EV2W8D_0.S1 11.4662f
C44 trim[5] a_n8227_n24218# 0.01271f
C45 vbg gf180mcu_ocd_ip__classab_buffer_0.se_folded_cascode_np_ab_0.outb1p 9.89359f
C46 x1.pnp_05p00x05p00_0_0[0|0].E x1.gf180mcu_as_sc_mcu7t3v3__buff_2_14.Y 0.33317f
C47 x1.gf180mcu_as_sc_mcu7t3v3__buff_2_3.Y a_n8227_n26906# 0.21504f
C48 trim[3] x1.gf180mcu_as_sc_mcu7t3v3__buff_2_4.Y 0.02412f
C49 trim[14] a_n8227_n16826# 0.25685f
C50 x1.nfet_03v3_EV2W8D_0.S1 x1.xtr.nfet_03v3_GP977X_0.S8 0.02172f
C51 trim[12] x1.gf180mcu_as_sc_mcu7t3v3__buff_2_13.Y 0.02447f
C52 a_n3700_n22079# x1.nfet_03v3_EV2W8D_0.S1 0.07094f
C53 dvdd gf180mcu_ocd_ip__classab_buffer_0.se_folded_cascode_np_ab_0.vbn2 2.80686f
C54 gf180mcu_ocd_ip__classab_buffer_0.se_folded_cascode_np_ab_0.outa1p x1.ena_buf 0.09567f
C55 gf180mcu_ocd_ip__classab_buffer_0.se_folded_cascode_np_ab_0.nfet_03v3_XRMCLC_0.S0_0 x1.ena_buf 1.06661f
C56 gf180mcu_ocd_ip__classab_buffer_0.se_folded_cascode_np_ab_0.outa1p gf180mcu_ocd_ip__classab_buffer_0.se_folded_cascode_np_ab_0.outa1n 25.7856f
C57 trim[3] a_n8227_n26010# 0.01273f
C58 trim[8] a_n8227_n22202# 0.25823f
C59 a_n598_n19279# a_n598_n20119# 0.02567f
C60 ibias2_1u gf180mcu_ocd_ip__classab_buffer_0.se_folded_cascode_np_ab_0.pfet_03v3_9TM96F_0.G0_0 0.0324f
C61 dvdd x1.xamp.vbn1 0.04959f
C62 x1.vbg gf180mcu_ocd_ip__classab_buffer_0.se_folded_cascode_np_ab_0.vbp1 0.01416f
C63 trim[5] x1.gf180mcu_as_sc_mcu7t3v3__buff_2_5.Y 0.04175f
C64 gf180mcu_ocd_ip__classab_buffer_0.se_folded_cascode_np_ab_0.outb1n gf180mcu_ocd_ip__classab_buffer_0.se_folded_cascode_np_ab_0.pfet_03v3_9TM96F_0.G0_0 3.44348f
C65 trim[10] x1.gf180mcu_as_sc_mcu7t3v3__buff_2_11.Y 0.02406f
C66 dvdd x1.xamp.pfet_03v3_EQVFPB_0.S1_0 8.55621f
C67 trim[8] trim[9] 0.02197f
C68 ibias1_250n x1.xamp.pfet_03v3_VL4T3E_0.S1_0 0.0713f
C69 x1.gf180mcu_as_sc_mcu7t3v3__buff_2_3.Y x1.gf180mcu_as_sc_mcu7t3v3__buff_2_4.Y 0.31822f
C70 trim[14] x1.gf180mcu_as_sc_mcu7t3v3__buff_2_15.Y 0.0247f
C71 x1.xtr.nfet_03v3_GP977X_0.S10 x1.xtr.nfet_03v3_GP977X_0.S11 0.14863f
C72 x1.pnp_05p00x05p00_0_0[0|0].E x1.xtr.nfet_03v3_GP977X_0.S5 0.1604f
C73 dvdd x1.xamp.vbp1 16.4748f
C74 trim[0] x1.gf180mcu_as_sc_mcu7t3v3__buff_2_1.Y 0.02445f
C75 x1.xamp.vbn1 x1.nfet_03v3_EV2W8D_0.S1 0.3102f
C76 x1.xamp.out1n x1.xamp.inp 3.56778f
C77 trim[5] a_n8227_n25114# 0.25496f
C78 x1.xamp.pfet_03v3_EQVFPB_0.S1_0 x1.nfet_03v3_EV2W8D_0.S1 2.83601f
C79 x1.pnp_05p00x05p00_0_0[0|0].E x1.gf180mcu_as_sc_mcu7t3v3__buff_2_15.Y 0.35731f
C80 gf180mcu_ocd_ip__classab_buffer_0.se_folded_cascode_np_ab_0.vbn1 gf180mcu_ocd_ip__classab_buffer_0.se_folded_cascode_np_ab_0.outb1n 5.97444f
C81 trim[10] a_n8227_n19514# 0.01267f
C82 x1.vbg x1.xtr.nfet_03v3_GP977X_0.S12 0.0173f
C83 trim[14] a_n8227_n15930# 0.01248f
C84 dvdd x1.nfet_03v3_EV2W8D_0.S1 11.912f
C85 trim[8] x1.gf180mcu_as_sc_mcu7t3v3__buff_2_9.Y 0.02421f
C86 x1.xamp.pfet_03v3_VL4T3E_0.S1_0 x1.xamp.out1n 4.74866f
C87 gf180mcu_ocd_ip__classab_buffer_0.se_folded_cascode_np_ab_0.vbn2 gf180mcu_ocd_ip__classab_buffer_0.se_folded_cascode_np_ab_0.pfet_03v3_XWLNX2_0.D 10.6776f
C88 gf180mcu_ocd_ip__classab_buffer_0.se_folded_cascode_np_ab_0.vbn1 gf180mcu_ocd_ip__classab_buffer_0.se_folded_cascode_np_ab_0.nfet_03v3_XHQ8ZW_0.S0_0 1.43951f
C89 trim[0] a_n8227_n28698# 0.01262f
C90 x1.gf180mcu_as_sc_mcu7t3v3__buff_2_4.Y x1.xtr.nfet_03v3_GP977X_0.S11 0.03962f
C91 trim[11] x1.gf180mcu_as_sc_mcu7t3v3__buff_2_11.Y 0.03629f
C92 x1.vbg gf180mcu_ocd_ip__classab_buffer_0.se_folded_cascode_np_ab_0.outa1n 1.9301f
C93 trim[15] x1.gf180mcu_as_sc_mcu7t3v3__buff_2_15.Y 0.03662f
C94 trim[8] a_n8227_n21306# 0.01252f
C95 x1.pnp_05p00x05p00_0_0[1|1].E x1.vbg 0.70355f
C96 trim[11] a_n8227_n19514# 0.25681f
C97 dvdd gf180mcu_ocd_ip__classab_buffer_0.se_folded_cascode_np_ab_0.pfet_03v3_XWLNX2_0.D 15.6064f
C98 x1.xamp.pfet_03v3_VL4T3E_0.S1_0 x1.xamp.inp 4.43367f
C99 trim[15] a_n8227_n15930# 0.25649f
C100 dvdd x1.gf180mcu_as_sc_mcu7t3v3__buff_2_1.Y 0.16861f
C101 gf180mcu_ocd_ip__classab_buffer_0.se_folded_cascode_np_ab_0.pfet_03v3_9TM96F_0.G0_0 gf180mcu_ocd_ip__classab_buffer_0.se_folded_cascode_np_ab_0.outb1p 13.0776f
C102 trim[7] x1.gf180mcu_as_sc_mcu7t3v3__buff_2_7.Y 0.0421f
C103 a_n598_n18999# a_n598_n18159# 0.02567f
C104 gf180mcu_ocd_ip__classab_buffer_0.se_folded_cascode_np_ab_0.vbn2 gf180mcu_ocd_ip__classab_buffer_0.se_folded_cascode_np_ab_0.vbp1 1.33473f
C105 ibias2_1u gf180mcu_ocd_ip__classab_buffer_0.se_folded_cascode_np_ab_0.diffb 0.70866f
C106 trim[14] trim[13] 0.02183f
C107 gf180mcu_ocd_ip__classab_buffer_0.se_folded_cascode_np_ab_0.diffb gf180mcu_ocd_ip__classab_buffer_0.se_folded_cascode_np_ab_0.outb1n 5.3862f
C108 x1.xamp.pfet_03v3_EQVFPB_0.G1_0 x1.ena_buf 0.07194f
C109 dvdd a_n8227_n28698# 0.36016f
C110 trim[11] x1.gf180mcu_as_sc_mcu7t3v3__buff_2_12.Y 0.02365f
C111 gf180mcu_ocd_ip__classab_buffer_0.se_folded_cascode_np_ab_0.vbn1 gf180mcu_ocd_ip__classab_buffer_0.se_folded_cascode_np_ab_0.outb1p 3.31954f
C112 x1.vbg x1.xtr.nfet_03v3_GP977X_0.S11 0.01781f
C113 trim[7] a_n8227_n23322# 0.25451f
C114 a_n8227_n17722# x1.gf180mcu_as_sc_mcu7t3v3__buff_2_13.Y 0.21923f
C115 x1.vbg x1.pfet_03v3_BWTVHK_0.D 0.62995f
C116 gf180mcu_ocd_ip__classab_buffer_0.se_folded_cascode_np_ab_0.diffb gf180mcu_ocd_ip__classab_buffer_0.se_folded_cascode_np_ab_0.nfet_03v3_XHQ8ZW_0.S0_0 0.024f
C117 x1.vbg x1.pfet_03v3_73PQE5_0.S0 0.70709f
C118 x1.pnp_05p00x05p00_0_0[0|0].E x1.xtr.nfet_03v3_GP977X_0.S7 0.16036f
C119 x1.xamp.inp x1.pnp_05p00x05p00_0_0[0|0].E 0.21821f
C120 ena x1.ena_buf 0.04053f
C121 vbg gf180mcu_ocd_ip__classab_buffer_0.se_folded_cascode_np_ab_0.pfet_03v3_9TM96F_0.G0_0 8.18434f
C122 x1.vbg x1.xtr.nfet_03v3_GP977X_0.S13 0.0173f
C123 dvdd gf180mcu_ocd_ip__classab_buffer_0.se_folded_cascode_np_ab_0.vbp1 14.7092f
C124 trim[11] a_n8227_n18618# 0.0127f
C125 x1.xtr.nfet_03v3_GP977X_0.S1 x1.gf180mcu_as_sc_mcu7t3v3__buff_2_14.Y 0.04053f
C126 x1.xamp.pfet_03v3_EQVFPB_0.S1_1 x1.xamp.pfet_03v3_EQVFPB_0.G1_0 7.09693f
C127 dvdd trim[5] 0.31384f
C128 a_n3700_n18719# a_n3700_n18439# 0.29949f
C129 x1.nfet_03v3_EV2W8D_0.S1 x1.xtr.nfet_03v3_GP977X_0.S6 0.02152f
C130 dvdd x1.gf180mcu_as_sc_mcu7t3v3__buff_2_2.Y 0.16949f
C131 gf180mcu_ocd_ip__classab_buffer_0.se_folded_cascode_np_ab_0.vbn2 x1.ena_buf 0.03146f
C132 gf180mcu_ocd_ip__classab_buffer_0.se_folded_cascode_np_ab_0.vbn2 gf180mcu_ocd_ip__classab_buffer_0.se_folded_cascode_np_ab_0.outa1n 0.18759f
C133 ena a_n8227_n15034# 0.25529f
C134 gf180mcu_ocd_ip__classab_buffer_0.se_folded_cascode_np_ab_0.vbn1 vbg 1.4518f
C135 trim[7] x1.gf180mcu_as_sc_mcu7t3v3__buff_2_8.Y 0.01396f
C136 x1.gf180mcu_as_sc_mcu7t3v3__buff_2_14.Y x1.gf180mcu_as_sc_mcu7t3v3__buff_2_13.Y 0.20355f
C137 dvdd a_n8227_n27802# 0.36016f
C138 dvdd trim[3] 0.31428f
C139 trim[1] trim[0] 0.02199f
C140 ibias1_250n x1.xamp.out1p 0.12783f
C141 a_n8227_n28698# x1.gf180mcu_as_sc_mcu7t3v3__buff_2_1.Y 0.21547f
C142 dvdd x1.ena_buf 18.3483f
C143 x1.xtr.nfet_03v3_GP977X_0.S9 x1.xtr.nfet_03v3_GP977X_0.S10 0.14863f
C144 dvdd gf180mcu_ocd_ip__classab_buffer_0.se_folded_cascode_np_ab_0.outa1n 21.526f
C145 x1.xamp.vbp1 x1.ena_buf 0.38321f
C146 x1.pnp_05p00x05p00_0_0[0|0].E x1.xtr.nfet_03v3_GP977X_0.S3 0.16039f
C147 gf180mcu_ocd_ip__classab_buffer_0.se_folded_cascode_np_ab_0.diffb gf180mcu_ocd_ip__classab_buffer_0.se_folded_cascode_np_ab_0.outb1p 4.99932f
C148 dvdd x1.gf180mcu_as_sc_mcu7t3v3__buff_2_10.Y 0.16572f
C149 trim[15] trim[14] 0.02167f
C150 gf180mcu_ocd_ip__classab_buffer_0.se_folded_cascode_np_ab_0.vbp1 gf180mcu_ocd_ip__classab_buffer_0.se_folded_cascode_np_ab_0.pfet_03v3_XWLNX2_0.D 0.04326f
C151 x1.xamp.vbn2 x1.xamp.pfet_03v3_EQVFPB_0.G1_0 2.23301f
C152 dvdd x1.pnp_05p00x05p00_0_0[1|1].E 7.04422f
C153 x1.nfet_03v3_EV2W8D_0.S1 x1.ena_buf 1.11882f
C154 x1.xamp.pfet_03v3_EQVFPB_0.S1_1 x1.xamp.pfet_03v3_EQVFPB_0.S1_0 11.883f
C155 dvdd a_n8227_n15034# 0.36576f
C156 x1.nfet_03v3_EV2W8D_0.S1 x1.xtr.nfet_03v3_GP977X_0.S2 0.02113f
C157 dvdd x1.gf180mcu_as_sc_mcu7t3v3__buff_2_3.Y 0.16722f
C158 x1.xamp.out1p x1.xamp.out1n 20.3271f
C159 dvdd x1.xamp.pfet_03v3_EQVFPB_0.S1_1 11.4251f
C160 x1.xtr.nfet_03v3_GP977X_0.S9 x1.gf180mcu_as_sc_mcu7t3v3__buff_2_6.Y 0.03962f
C161 dvdd a_n8227_n20410# 0.36021f
C162 x1.gf180mcu_as_sc_mcu7t3v3__buff_2_2.Y x1.gf180mcu_as_sc_mcu7t3v3__buff_2_1.Y 0.33604f
C163 x1.pnp_05p00x05p00_0_0[1|1].E x1.nfet_03v3_EV2W8D_0.S1 1.26733f
C164 x1.gf180mcu_as_sc_mcu7t3v3__buff_2_0.Y x1.pnp_05p00x05p00_0_0[0|0].E 0.71809f
C165 x1.xtr.top x1.gf180mcu_as_sc_mcu7t3v3__buff_2_15.Y 0.04996f
C166 gf180mcu_ocd_ip__classab_buffer_0.se_folded_cascode_np_ab_0.diffb vbg 1.88223f
C167 dvdd trim[7] 0.32839f
C168 x1.xamp.pfet_03v3_EQVFPB_0.S1_1 x1.nfet_03v3_EV2W8D_0.S1 6.13023f
C169 ibias2_1u gf180mcu_ocd_ip__classab_buffer_0.se_folded_cascode_np_ab_0.outa1p 0.02594f
C170 dvdd trim[1] 0.31377f
C171 gf180mcu_ocd_ip__classab_buffer_0.se_folded_cascode_np_ab_0.outb1n gf180mcu_ocd_ip__classab_buffer_0.se_folded_cascode_np_ab_0.outa1p 0.20736f
C172 a_n3700_n16199# x1.xtr.top 0.05787f
C173 dvdd trim[12] 0.31364f
C174 gf180mcu_ocd_ip__classab_buffer_0.se_folded_cascode_np_ab_0.pfet_03v3_XWLNX2_0.D x1.ena_buf 0.6856f
C175 gf180mcu_ocd_ip__classab_buffer_0.se_folded_cascode_np_ab_0.nfet_03v3_XRMCLC_0.S0_0 gf180mcu_ocd_ip__classab_buffer_0.se_folded_cascode_np_ab_0.outb1n 0.0451f
C176 gf180mcu_ocd_ip__classab_buffer_0.se_folded_cascode_np_ab_0.pfet_03v3_XWLNX2_0.D gf180mcu_ocd_ip__classab_buffer_0.se_folded_cascode_np_ab_0.outa1n 14.3437f
C177 x1.xamp.out1p x1.xamp.inp 0.61328f
C178 dvdd x1.pfet_03v3_BWTVHK_0.D 2.56879f
C179 dvdd x1.pfet_03v3_73PQE5_0.S0 1.61108f
C180 a_n3700_n19559# a_n3700_n19839# 0.29949f
C181 x1.pnp_05p00x05p00_0_0[0|0].E x1.gf180mcu_as_sc_mcu7t3v3__buff_2_11.Y 0.33453f
C182 gf180mcu_ocd_ip__classab_buffer_0.se_folded_cascode_np_ab_0.nfet_03v3_XHQ8ZW_0.S0_0 gf180mcu_ocd_ip__classab_buffer_0.se_folded_cascode_np_ab_0.outa1p 2.82772f
C183 x1.xamp.vbn2 x1.xamp.vbn1 4.91436f
C184 x1.pnp_05p00x05p00_0_0[0|0].E x1.xtr.nfet_03v3_GP977X_0.S14 0.16189f
C185 x1.xamp.out1p x1.xamp.pfet_03v3_VL4T3E_0.S1_0 7.83641f
C186 x1.gf180mcu_as_sc_mcu7t3v3__buff_2_8.Y a_n8227_n22202# 0.21275f
C187 x1.xamp.vbn2 x1.xamp.pfet_03v3_EQVFPB_0.S1_0 0.0295f
C188 x1.nfet_03v3_EV2W8D_0.S1 x1.pfet_03v3_BWTVHK_0.D 1.40821f
C189 x1.pfet_03v3_73PQE5_0.S0 x1.nfet_03v3_EV2W8D_0.S1 1.97825f
C190 dvdd x1.xamp.vbn2 3.19623f
C191 a_n598_n21519# x1.vbg 0.04712f
C192 gf180mcu_ocd_ip__classab_buffer_0.se_folded_cascode_np_ab_0.vbn1 gf180mcu_ocd_ip__classab_buffer_0.se_folded_cascode_np_ab_0.pfet_03v3_9TM96F_0.G0_0 0.01405f
C193 x1.xamp.vbn2 x1.xamp.vbp1 3.81642f
C194 x1.nfet_03v3_EV2W8D_0.S1 a_n3700_n20959# 0.07135f
C195 a_n8227_n29594# x1.gf180mcu_as_sc_mcu7t3v3__buff_2_0.Y 0.22938f
C196 a_n3700_n17599# x1.nfet_03v3_EV2W8D_0.S1 0.07161f
C197 x1.xamp.vbn2 x1.nfet_03v3_EV2W8D_0.S1 6.81294f
C198 ibias2_1u x1.vbg 0.52856f
C199 gf180mcu_ocd_ip__classab_buffer_0.se_folded_cascode_np_ab_0.vbp1 x1.ena_buf 1.67138f
C200 x1.vbg gf180mcu_ocd_ip__classab_buffer_0.se_folded_cascode_np_ab_0.outb1n 0.38f
C201 a_n8227_n27802# x1.gf180mcu_as_sc_mcu7t3v3__buff_2_2.Y 0.2243f
C202 x1.gf180mcu_as_sc_mcu7t3v3__buff_2_8.Y x1.gf180mcu_as_sc_mcu7t3v3__buff_2_9.Y 0.23789f
C203 gf180mcu_ocd_ip__classab_buffer_0.se_folded_cascode_np_ab_0.vbp1 gf180mcu_ocd_ip__classab_buffer_0.se_folded_cascode_np_ab_0.outa1n 0.13839f
C204 trim[1] x1.gf180mcu_as_sc_mcu7t3v3__buff_2_1.Y 0.04296f
C205 trim[13] x1.gf180mcu_as_sc_mcu7t3v3__buff_2_13.Y 0.03888f
C206 x1.pnp_05p00x05p00_0_0[0|0].E x1.gf180mcu_as_sc_mcu7t3v3__buff_2_12.Y 0.33396f
C207 x1.vbg gf180mcu_ocd_ip__classab_buffer_0.se_folded_cascode_np_ab_0.nfet_03v3_XHQ8ZW_0.S0_0 1.36558f
C208 x1.xtr.nfet_03v3_GP977X_0.S3 x1.gf180mcu_as_sc_mcu7t3v3__buff_2_12.Y 0.04021f
C209 a_n3700_n21799# a_n3700_n22079# 0.29949f
C210 gf180mcu_ocd_ip__classab_buffer_0.se_folded_cascode_np_ab_0.outb1p gf180mcu_ocd_ip__classab_buffer_0.se_folded_cascode_np_ab_0.outa1p 0.26034f
C211 x1.xtr.nfet_03v3_GP977X_0.S15 x1.pfet_03v3_BWTVHK_0.D 0.01898f
C212 x1.nfet_03v3_EV2W8D_0.S1 a_n3700_n20679# 0.05396f
C213 trim[1] a_n8227_n28698# 0.255f
C214 a_n3700_n17319# x1.nfet_03v3_EV2W8D_0.S1 0.05533f
C215 dvdd a_n8227_n22202# 0.36168f
C216 x1.gf180mcu_as_sc_mcu7t3v3__buff_2_3.Y x1.gf180mcu_as_sc_mcu7t3v3__buff_2_2.Y 0.33092f
C217 a_n8227_n19514# x1.gf180mcu_as_sc_mcu7t3v3__buff_2_11.Y 0.21759f
C218 dvdd trim[9] 0.31376f
C219 gf180mcu_ocd_ip__classab_buffer_0.se_folded_cascode_np_ab_0.outa1n x1.ena_buf 1.24078f
C220 x1.nfet_03v3_EV2W8D_0.S1 a_n598_n20399# 0.06766f
C221 x1.xtr.nfet_03v3_GP977X_0.S8 x1.xtr.nfet_03v3_GP977X_0.S9 0.14863f
C222 x1.gf180mcu_as_sc_mcu7t3v3__buff_2_3.Y x1.xtr.nfet_03v3_GP977X_0.S12 0.03971f
C223 x1.pnp_05p00x05p00_0_0[0|0].E x1.xtr.nfet_03v3_GP977X_0.S1 0.16031f
C224 a_n598_n17039# x1.nfet_03v3_EV2W8D_0.S1 0.07313f
C225 trim[3] x1.gf180mcu_as_sc_mcu7t3v3__buff_2_3.Y 0.0419f
C226 vbg gf180mcu_ocd_ip__classab_buffer_0.se_folded_cascode_np_ab_0.outa1p 3.13788f
C227 trim[1] x1.gf180mcu_as_sc_mcu7t3v3__buff_2_2.Y 0.02375f
C228 gf180mcu_ocd_ip__classab_buffer_0.se_folded_cascode_np_ab_0.nfet_03v3_XRMCLC_0.S0_0 vbg 8.14147f
C229 a_n8227_n15034# x1.ena_buf 0.24439f
C230 x1.xamp.pfet_03v3_EQVFPB_0.S1_1 x1.ena_buf 0.01662f
C231 x1.pnp_05p00x05p00_0_0[0|0].E x1.gf180mcu_as_sc_mcu7t3v3__buff_2_13.Y 0.33341f
C232 dvdd x1.gf180mcu_as_sc_mcu7t3v3__buff_2_9.Y 0.16406f
C233 x1.gf180mcu_as_sc_mcu7t3v3__buff_2_12.Y x1.gf180mcu_as_sc_mcu7t3v3__buff_2_11.Y 0.20659f
C234 x1.vbg gf180mcu_ocd_ip__classab_buffer_0.se_folded_cascode_np_ab_0.outb1p 2.27253f
C235 x1.pnp_05p00x05p00_0_0[0|0].E x1.xtr.top 0.17537f
C236 x1.nfet_03v3_EV2W8D_0.S1 a_n3700_n18439# 0.05533f
C237 dvdd a_n8227_n17722# 0.36021f
C238 ibias2_1u gf180mcu_ocd_ip__classab_buffer_0.se_folded_cascode_np_ab_0.vbn2 0.54103f
C239 x1.xtr.nfet_03v3_GP977X_0.S11 x1.xtr.nfet_03v3_GP977X_0.S12 0.14863f
C240 trim[1] a_n8227_n27802# 0.0127f
C241 x1.gf180mcu_as_sc_mcu7t3v3__buff_2_2.Y x1.xtr.nfet_03v3_GP977X_0.S13 0.03994f
C242 a_n8227_n20410# x1.gf180mcu_as_sc_mcu7t3v3__buff_2_10.Y 0.2222f
C243 gf180mcu_ocd_ip__classab_buffer_0.se_folded_cascode_np_ab_0.vbn2 gf180mcu_ocd_ip__classab_buffer_0.se_folded_cascode_np_ab_0.outb1n 6.10332f
C244 dvdd trim[10] 0.31352f
C245 x1.xtr.nfet_03v3_GP977X_0.S12 x1.pfet_03v3_BWTVHK_0.D 0.01904f
C246 x1.nfet_03v3_EV2W8D_0.S1 a_n598_n20119# 0.05511f
C247 dvdd a_n8227_n21306# 0.36021f
C248 a_n3700_n21799# x1.nfet_03v3_EV2W8D_0.S1 0.05534f
C249 a_n598_n16759# x1.nfet_03v3_EV2W8D_0.S1 0.08541f
C250 x1.xtr.nfet_03v3_GP977X_0.S12 x1.xtr.nfet_03v3_GP977X_0.S13 0.14864f
C251 x1.nfet_03v3_EV2W8D_0.S1 a_n598_n18159# 0.07203f
C252 x1.pnp_05p00x05p00_0_0[0|0].E x1.xtr.nfet_03v3_GP977X_0.S10 0.16039f
C253 dvdd x1.gf180mcu_as_sc_mcu7t3v3__buff_2_14.Y 0.16289f
C254 x1.vbg vbg 5.1808f
C255 dvdd ibias2_1u 5.72883f
C256 a_n598_n21519# x1.nfet_03v3_EV2W8D_0.S1 0.07206f
C257 dvdd gf180mcu_ocd_ip__classab_buffer_0.se_folded_cascode_np_ab_0.outb1n 2.2757f
C258 a_n598_n18999# a_n598_n19279# 0.3001f
C259 x1.nfet_03v3_EV2W8D_0.S1 x1.xtr.nfet_03v3_GP977X_0.S9 0.02361f
C260 x1.pnp_05p00x05p00_0_0[1|1].E x1.pfet_03v3_BWTVHK_0.D 3.74328f
C261 x1.pnp_05p00x05p00_0_0[1|1].E x1.pfet_03v3_73PQE5_0.S0 0.03577f
C262 x1.xamp.vbn2 x1.ena_buf 0.22749f
C263 ibias1_250n x1.xamp.pfet_03v3_EQVFPB_0.G1_0 4.23972f
C264 dvdd trim[11] 0.31387f
C265 dvdd gf180mcu_ocd_ip__classab_buffer_0.se_folded_cascode_np_ab_0.nfet_03v3_XHQ8ZW_0.S0_0 0.19914f
C266 x1.pnp_05p00x05p00_0_0[0|0].E x1.gf180mcu_as_sc_mcu7t3v3__buff_2_4.Y 0.34014f
C267 x1.pnp_05p00x05p00_0_0[0|0].E x1.gf180mcu_as_sc_mcu7t3v3__buff_2_6.Y 0.33629f
C268 dvdd a_n8227_n16826# 0.36021f
C269 x1.vbg x1.xamp.inp 0.43604f
C270 x1.nfet_03v3_EV2W8D_0.S1 a_n598_n17879# 0.08422f
C271 a_n8227_n18618# x1.gf180mcu_as_sc_mcu7t3v3__buff_2_12.Y 0.22482f
C272 x1.xamp.vbn2 x1.xamp.pfet_03v3_EQVFPB_0.S1_1 0.02015f
C273 a_n598_n21239# x1.nfet_03v3_EV2W8D_0.S1 0.0859f
C274 x1.nfet_03v3_EV2W8D_0.S1 a_n3700_n16479# 0.07288f
C275 x1.xamp.out1n x1.xamp.pfet_03v3_EQVFPB_0.G1_0 4.75981f
C276 x1.xtr.nfet_03v3_GP977X_0.S4 x1.xtr.nfet_03v3_GP977X_0.S5 0.14864f
C277 gf180mcu_ocd_ip__classab_buffer_0.se_folded_cascode_np_ab_0.vbn2 gf180mcu_ocd_ip__classab_buffer_0.se_folded_cascode_np_ab_0.outb1p 9.67763f
C278 a_n3700_n18719# a_n3700_n19559# 0.02567f
C279 x1.xtr.nfet_03v3_GP977X_0.S6 x1.gf180mcu_as_sc_mcu7t3v3__buff_2_9.Y 0.03962f
C280 dvdd x1.gf180mcu_as_sc_mcu7t3v3__buff_2_15.Y 0.16585f
C281 ibias2_1u gf180mcu_ocd_ip__classab_buffer_0.se_folded_cascode_np_ab_0.pfet_03v3_XWLNX2_0.D 0.06464f
C282 gf180mcu_ocd_ip__classab_buffer_0.se_folded_cascode_np_ab_0.pfet_03v3_9TM96F_0.G0_0 gf180mcu_ocd_ip__classab_buffer_0.se_folded_cascode_np_ab_0.outa1p 18.317f
C283 trim[2] a_n8227_n26906# 0.01267f
C284 gf180mcu_ocd_ip__classab_buffer_0.se_folded_cascode_np_ab_0.outb1n gf180mcu_ocd_ip__classab_buffer_0.se_folded_cascode_np_ab_0.pfet_03v3_XWLNX2_0.D 13.6153f
C285 x1.xtr.nfet_03v3_GP977X_0.S13 x1.pfet_03v3_BWTVHK_0.D 0.01898f
C286 trim[4] x1.gf180mcu_as_sc_mcu7t3v3__buff_2_4.Y 0.04171f
C287 ibias1_250n x1.xamp.pfet_03v3_EQVFPB_0.S1_0 1.95846f
C288 x1.gf180mcu_as_sc_mcu7t3v3__buff_2_13.Y x1.gf180mcu_as_sc_mcu7t3v3__buff_2_12.Y 0.20442f
C289 x1.xtr.nfet_03v3_GP977X_0.S7 x1.gf180mcu_as_sc_mcu7t3v3__buff_2_8.Y 0.03962f
C290 x1.pnp_05p00x05p00_0_0[0|0].E x1.gf180mcu_as_sc_mcu7t3v3__buff_2_7.Y 0.3387f
C291 x1.pnp_05p00x05p00_0_0[0|0].E x1.gf180mcu_as_sc_mcu7t3v3__buff_2_5.Y 0.34019f
C292 gf180mcu_ocd_ip__classab_buffer_0.se_folded_cascode_np_ab_0.nfet_03v3_XHQ8ZW_0.S0_0 gf180mcu_ocd_ip__classab_buffer_0.se_folded_cascode_np_ab_0.pfet_03v3_XWLNX2_0.D 0.02181f
C293 dvdd a_n8227_n15930# 0.36021f
C294 gf180mcu_ocd_ip__classab_buffer_0.se_folded_cascode_np_ab_0.vbn1 gf180mcu_ocd_ip__classab_buffer_0.se_folded_cascode_np_ab_0.outa1p 0.02973f
C295 dvdd ibias1_250n 14.8068f
C296 x1.vbg x1.pnp_05p00x05p00_0_0[0|0].E 0.6855f
C297 dvdd gf180mcu_ocd_ip__classab_buffer_0.se_folded_cascode_np_ab_0.outb1p 2.23524f
C298 gf180mcu_ocd_ip__classab_buffer_0.se_folded_cascode_np_ab_0.nfet_03v3_XRMCLC_0.S0_0 gf180mcu_ocd_ip__classab_buffer_0.se_folded_cascode_np_ab_0.vbn1 0.01412f
C299 ibias1_250n x1.xamp.vbp1 2.8665f
C300 gf180mcu_ocd_ip__classab_buffer_0.se_folded_cascode_np_ab_0.vbn2 vbg 5.77907f
C301 x1.nfet_03v3_EV2W8D_0.S1 a_n3700_n16199# 0.0547f
C302 x1.xtr.nfet_03v3_GP977X_0.S7 x1.xtr.nfet_03v3_GP977X_0.S8 0.14863f
C303 trim[4] a_n8227_n26010# 0.25427f
C304 x1.xamp.pfet_03v3_VL4T3E_0.S1_0 x1.xamp.pfet_03v3_EQVFPB_0.G1_0 0.01251f
C305 trim[9] x1.gf180mcu_as_sc_mcu7t3v3__buff_2_10.Y 0.02407f
C306 x1.xamp.vbn1 x1.xamp.out1n 3.72713f
C307 ibias1_250n x1.nfet_03v3_EV2W8D_0.S1 2.24145f
C308 x1.xamp.out1n x1.xamp.pfet_03v3_EQVFPB_0.S1_0 0.12643f
C309 ibias2_1u gf180mcu_ocd_ip__classab_buffer_0.se_folded_cascode_np_ab_0.vbp1 3.38609f
C310 dvdd x1.xamp.out1n 4.80969f
C311 x1.vbg x1.nfet_03v3_EV2W8D_0.S0 0.24629f
C312 trim[9] a_n8227_n20410# 0.01261f
C313 dvdd vbg 14.8117f
C314 a_n3700_n20679# a_n3700_n20959# 0.29949f
C315 x1.gf180mcu_as_sc_mcu7t3v3__buff_2_10.Y x1.gf180mcu_as_sc_mcu7t3v3__buff_2_9.Y 0.21291f
C316 x1.xtr.top x1.xtr.nfet_03v3_GP977X_0.S1 0.14902f
C317 trim[4] x1.gf180mcu_as_sc_mcu7t3v3__buff_2_5.Y 0.02424f
C318 a_n3700_n17319# a_n3700_n17599# 0.29949f
C319 x1.xamp.out1n x1.nfet_03v3_EV2W8D_0.S1 2.40075f
C320 x1.pnp_05p00x05p00_0_0[1|1].E a_n598_n16759# 0.04923f
C321 x1.pnp_05p00x05p00_0_0[0|0].E x1.gf180mcu_as_sc_mcu7t3v3__buff_2_8.Y 0.33718f
C322 gf180mcu_ocd_ip__classab_buffer_0.se_folded_cascode_np_ab_0.vbn1 x1.vbg 0.0877f
C323 trim[10] x1.gf180mcu_as_sc_mcu7t3v3__buff_2_10.Y 0.03646f
C324 gf180mcu_ocd_ip__classab_buffer_0.se_folded_cascode_np_ab_0.pfet_03v3_XWLNX2_0.D gf180mcu_ocd_ip__classab_buffer_0.se_folded_cascode_np_ab_0.outb1p 6.74392f
C325 dvdd trim[13] 0.31277f
C326 dvdd x1.xamp.inp 5.83055f
C327 x1.pnp_05p00x05p00_0_0[0|0].E x1.xtr.nfet_03v3_GP977X_0.S8 0.16031f
C328 x1.xtr.nfet_03v3_GP977X_0.S6 x1.xtr.nfet_03v3_GP977X_0.S5 0.14863f
C329 trim[4] a_n8227_n25114# 0.01282f
C330 x1.vbg x1.xtr.nfet_03v3_GP977X_0.S14 0.0173f
C331 ibias2_1u x1.ena_buf 2.34524f
C332 ibias2_1u gf180mcu_ocd_ip__classab_buffer_0.se_folded_cascode_np_ab_0.outa1n 0.14159f
C333 trim[6] x1.gf180mcu_as_sc_mcu7t3v3__buff_2_6.Y 0.04305f
C334 trim[10] a_n8227_n20410# 0.25704f
C335 dvdd x1.xamp.pfet_03v3_VL4T3E_0.S1_0 15.9334f
C336 gf180mcu_ocd_ip__classab_buffer_0.se_folded_cascode_np_ab_0.outb1n gf180mcu_ocd_ip__classab_buffer_0.se_folded_cascode_np_ab_0.outa1n 0.17966f
C337 x1.xamp.pfet_03v3_VL4T3E_0.S1_0 x1.xamp.vbp1 2.18144f
C338 x1.nfet_03v3_EV2W8D_0.S1 x1.xtr.nfet_03v3_GP977X_0.S7 0.02148f
C339 x1.nfet_03v3_EV2W8D_0.S1 x1.xamp.inp 0.41273f
C340 trim[12] a_n8227_n17722# 0.01244f
C341 gf180mcu_ocd_ip__classab_buffer_0.se_folded_cascode_np_ab_0.nfet_03v3_XHQ8ZW_0.S0_0 gf180mcu_ocd_ip__classab_buffer_0.se_folded_cascode_np_ab_0.outa1n 2.73256f
C342 trim[6] a_n8227_n24218# 0.25457f
C343 a_n3700_n17599# a_n3700_n18439# 0.02567f
C344 ena trim[15] 0.02182f
C345 vbg gf180mcu_ocd_ip__classab_buffer_0.se_folded_cascode_np_ab_0.pfet_03v3_XWLNX2_0.D 25.7813f
C346 trim[0] x1.gf180mcu_as_sc_mcu7t3v3__buff_2_0.Y 0.03816f
C347 dvdd trim[14] 0.31289f
C348 a_n3700_n21799# a_n3700_n20959# 0.02567f
C349 gf180mcu_ocd_ip__classab_buffer_0.se_folded_cascode_np_ab_0.vbn2 gf180mcu_ocd_ip__classab_buffer_0.se_folded_cascode_np_ab_0.pfet_03v3_9TM96F_0.G0_0 10.5111f
C350 dvdd x1.pnp_05p00x05p00_0_0[0|0].E 0.14181f
C351 trim[0] a_n8227_n29594# 0.25474f
C352 x1.pnp_05p00x05p00_0_0[0|0].E x1.xtr.nfet_03v3_GP977X_0.S4 0.1604f
C353 x1.xtr.nfet_03v3_GP977X_0.S3 x1.xtr.nfet_03v3_GP977X_0.S4 0.14864f
C354 gf180mcu_ocd_ip__classab_buffer_0.se_folded_cascode_np_ab_0.diffb x1.vbg 1.98513f
C355 x1.gf180mcu_as_sc_mcu7t3v3__buff_2_15.Y x1.ena_buf 0.02953f
C356 x1.gf180mcu_as_sc_mcu7t3v3__buff_2_10.Y x1.xtr.nfet_03v3_GP977X_0.S5 0.03984f
C357 trim[6] x1.gf180mcu_as_sc_mcu7t3v3__buff_2_7.Y 0.02411f
C358 x1.nfet_03v3_EV2W8D_0.S1 x1.pnp_05p00x05p00_0_0[0|0].E 0.27386f
C359 gf180mcu_ocd_ip__classab_buffer_0.se_folded_cascode_np_ab_0.vbn2 gf180mcu_ocd_ip__classab_buffer_0.se_folded_cascode_np_ab_0.vbn1 0.79644f
C360 x1.nfet_03v3_EV2W8D_0.S1 x1.xtr.nfet_03v3_GP977X_0.S3 0.02115f
C361 trim[12] trim[11] 0.02234f
C362 dvdd trim[15] 0.31296f
C363 a_n3700_n19839# x1.nfet_03v3_EV2W8D_0.S1 0.01894f
C364 trim[6] a_n8227_n23322# 0.01275f
C365 dvdd gf180mcu_ocd_ip__classab_buffer_0.se_folded_cascode_np_ab_0.pfet_03v3_9TM96F_0.G0_0 32.19f
C366 dvdd x1.nfet_03v3_EV2W8D_0.S0 0.22268f
C367 ibias1_250n x1.ena_buf 0.78368f
C368 dvdd x1.gf180mcu_as_sc_mcu7t3v3__buff_2_0.Y 0.17971f
C369 gf180mcu_ocd_ip__classab_buffer_0.se_folded_cascode_np_ab_0.outb1p gf180mcu_ocd_ip__classab_buffer_0.se_folded_cascode_np_ab_0.outa1n 0.59463f
C370 trim[8] x1.gf180mcu_as_sc_mcu7t3v3__buff_2_8.Y 0.03921f
C371 x1.xtr.nfet_03v3_GP977X_0.S6 x1.xtr.nfet_03v3_GP977X_0.S7 0.14863f
C372 a_n598_n20119# a_n598_n20399# 0.3001f
C373 x1.xamp.out1p x1.xamp.pfet_03v3_EQVFPB_0.G1_0 2.46352f
C374 dvdd trim[4] 0.31353f
C375 x1.nfet_03v3_EV2W8D_0.S0 x1.nfet_03v3_EV2W8D_0.S1 0.59366f
C376 a_n598_n16759# a_n598_n17039# 0.3001f
C377 dvdd a_n8227_n29594# 0.36f
C378 ibias1_250n x1.xamp.pfet_03v3_EQVFPB_0.S1_1 1.67006f
C379 dvdd x1.gf180mcu_as_sc_mcu7t3v3__buff_2_11.Y 0.16419f
C380 trim[9] x1.gf180mcu_as_sc_mcu7t3v3__buff_2_9.Y 0.03701f
C381 x1.gf180mcu_as_sc_mcu7t3v3__buff_2_1.Y x1.pnp_05p00x05p00_0_0[0|0].E 0.33773f
C382 x1.xtr.nfet_03v3_GP977X_0.S4 x1.gf180mcu_as_sc_mcu7t3v3__buff_2_11.Y 0.04004f
C383 vbg x1.ena_buf 0.74972f
C384 x1.pnp_05p00x05p00_0_0[0|0].E x1.xtr.nfet_03v3_GP977X_0.S15 0.31133f
C385 a_n3700_n19559# x1.nfet_03v3_EV2W8D_0.S1 0.04137f
C386 vbg gf180mcu_ocd_ip__classab_buffer_0.se_folded_cascode_np_ab_0.outa1n 1.80619f
C387 dvdd trim[2] 0.31402f
C388 a_n8227_n24218# x1.gf180mcu_as_sc_mcu7t3v3__buff_2_6.Y 0.2158f
C389 a_n8227_n26010# x1.gf180mcu_as_sc_mcu7t3v3__buff_2_4.Y 0.21464f
C390 trim[10] trim[9] 0.02227f
C391 x1.pnp_05p00x05p00_0_0[1|1].E x1.xamp.out1n 1.67853f
C392 trim[9] a_n8227_n21306# 0.25694f
C393 dvdd a_n8227_n19514# 0.36021f
C394 x1.gf180mcu_as_sc_mcu7t3v3__buff_2_5.Y x1.xtr.nfet_03v3_GP977X_0.S10 0.03962f
C395 x1.xamp.pfet_03v3_EQVFPB_0.S1_1 x1.xamp.out1n 0.0187f
C396 gf180mcu_ocd_ip__classab_buffer_0.se_folded_cascode_np_ab_0.pfet_03v3_XWLNX2_0.D gf180mcu_ocd_ip__classab_buffer_0.se_folded_cascode_np_ab_0.pfet_03v3_9TM96F_0.G0_0 34.3262f
C397 x1.vbg x1.xtr.nfet_03v3_GP977X_0.S10 0.03684f
C398 a_n598_n19279# x1.nfet_03v3_EV2W8D_0.S1 0.05366f
C399 x1.xamp.inp x1.ena_buf 0.01364f
C400 a_n3700_n17319# a_n3700_n16479# 0.02567f
C401 x1.gf180mcu_as_sc_mcu7t3v3__buff_2_1.Y x1.gf180mcu_as_sc_mcu7t3v3__buff_2_0.Y 0.31887f
C402 x1.pnp_05p00x05p00_0_0[0|0].E x1.xtr.nfet_03v3_GP977X_0.S6 0.16039f
C403 x1.xamp.out1p x1.xamp.vbn1 6.04108f
C404 a_n598_n17039# a_n598_n17879# 0.02567f
C405 x1.xamp.out1p x1.xamp.pfet_03v3_EQVFPB_0.S1_0 1.23486f
C406 x1.gf180mcu_as_sc_mcu7t3v3__buff_2_0.Y x1.xtr.nfet_03v3_GP977X_0.S15 0.04029f
C407 dvdd trim[8] 0.31715f
C408 a_n8227_n21306# x1.gf180mcu_as_sc_mcu7t3v3__buff_2_9.Y 0.21182f
C409 gf180mcu_ocd_ip__classab_buffer_0.se_folded_cascode_np_ab_0.vbn1 gf180mcu_ocd_ip__classab_buffer_0.se_folded_cascode_np_ab_0.pfet_03v3_XWLNX2_0.D 0.44959f
C410 a_n598_n21239# a_n598_n20399# 0.02567f
C411 dvdd x1.xamp.out1p 5.92733f
C412 x1.gf180mcu_as_sc_mcu7t3v3__buff_2_5.Y x1.gf180mcu_as_sc_mcu7t3v3__buff_2_4.Y 0.30997f
C413 x1.gf180mcu_as_sc_mcu7t3v3__buff_2_7.Y x1.gf180mcu_as_sc_mcu7t3v3__buff_2_6.Y 0.28901f
C414 x1.gf180mcu_as_sc_mcu7t3v3__buff_2_5.Y x1.gf180mcu_as_sc_mcu7t3v3__buff_2_6.Y 0.28459f
C415 x1.pnp_05p00x05p00_0_0[1|1].E x1.xamp.inp 6.67062f
C416 ibias1_250n x1.xamp.vbn2 0.98374f
C417 dvdd x1.gf180mcu_as_sc_mcu7t3v3__buff_2_12.Y 0.16524f
C418 x1.gf180mcu_as_sc_mcu7t3v3__buff_2_2.Y x1.pnp_05p00x05p00_0_0[0|0].E 0.34044f
C419 dvdd gf180mcu_ocd_ip__classab_buffer_0.se_folded_cascode_np_ab_0.diffb 7.60895f
C420 x1.vbg gf180mcu_ocd_ip__classab_buffer_0.se_folded_cascode_np_ab_0.outa1p 0.83794f
C421 x1.pnp_05p00x05p00_0_0[1|1].E x1.xamp.pfet_03v3_VL4T3E_0.S1_0 4.54216f
C422 x1.xamp.out1p x1.nfet_03v3_EV2W8D_0.S1 6.23027f
C423 x1.gf180mcu_as_sc_mcu7t3v3__buff_2_1.Y x1.xtr.nfet_03v3_GP977X_0.S14 0.04013f
C424 x1.pnp_05p00x05p00_0_0[0|0].E x1.xtr.nfet_03v3_GP977X_0.S12 0.16176f
C425 dvdd trim[6] 0.31432f
C426 dvdd a_n8227_n18618# 0.36021f
C427 x1.xtr.nfet_03v3_GP977X_0.S14 x1.xtr.nfet_03v3_GP977X_0.S15 0.14864f
C428 x1.xamp.vbn2 x1.xamp.out1n 3.55117f
C429 a_n598_n17879# a_n598_n18159# 0.3001f
C430 trim[13] trim[12] 0.02202f
C431 x1.pnp_05p00x05p00_0_0[0|0].E x1.ena_buf 0.0506f
C432 x1.pnp_05p00x05p00_0_0[0|0].E x1.xtr.nfet_03v3_GP977X_0.S2 0.16035f
C433 x1.xtr.nfet_03v3_GP977X_0.S2 x1.xtr.nfet_03v3_GP977X_0.S3 0.14865f
C434 x1.xamp.inp x1.pfet_03v3_BWTVHK_0.D 0.05091f
C435 x1.pnp_05p00x05p00_0_0[0|0].E x1.gf180mcu_as_sc_mcu7t3v3__buff_2_10.Y 0.33455f
C436 trim[11] trim[10] 0.02221f
C437 trim[5] trim[4] 0.02241f
C438 x1.pnp_05p00x05p00_0_0[1|1].E x1.pnp_05p00x05p00_0_0[0|0].E 2.50564f
C439 a_n598_n18999# x1.nfet_03v3_EV2W8D_0.S1 0.08311f
C440 dvdd x1.gf180mcu_as_sc_mcu7t3v3__buff_2_13.Y 0.1659f
C441 x1.nfet_03v3_EV2W8D_0.S1 x1.xtr.nfet_03v3_GP977X_0.S1 0.02113f
C442 x1.gf180mcu_as_sc_mcu7t3v3__buff_2_3.Y x1.pnp_05p00x05p00_0_0[0|0].E 0.34079f
C443 trim[15] x1.ena_buf 0.02314f
C444 a_n598_n21239# a_n598_n21519# 0.3001f
C445 gf180mcu_ocd_ip__classab_buffer_0.se_folded_cascode_np_ab_0.diffb gf180mcu_ocd_ip__classab_buffer_0.se_folded_cascode_np_ab_0.pfet_03v3_XWLNX2_0.D 0.01548f
C446 dvdd x1.xtr.top 0.07693f
C447 gf180mcu_ocd_ip__classab_buffer_0.se_folded_cascode_np_ab_0.pfet_03v3_9TM96F_0.G0_0 gf180mcu_ocd_ip__classab_buffer_0.se_folded_cascode_np_ab_0.outa1n 6.55421f
C448 a_n8227_n25114# x1.gf180mcu_as_sc_mcu7t3v3__buff_2_5.Y 0.21469f
C449 a_n8227_n23322# x1.gf180mcu_as_sc_mcu7t3v3__buff_2_7.Y 0.2149f
C450 trim[4] trim[3] 0.02221f
C451 x1.xamp.vbn2 x1.xamp.pfet_03v3_VL4T3E_0.S1_0 2.12245f
C452 a_n8227_n16826# x1.gf180mcu_as_sc_mcu7t3v3__buff_2_14.Y 0.21096f
C453 trim[2] x1.gf180mcu_as_sc_mcu7t3v3__buff_2_2.Y 0.04386f
C454 gf180mcu_ocd_ip__classab_buffer_0.se_folded_cascode_np_ab_0.nfet_03v3_XHQ8ZW_0.S0_0 gf180mcu_ocd_ip__classab_buffer_0.se_folded_cascode_np_ab_0.outb1n 0.34718f
C455 trim[15] a_n8227_n15034# 0.01271f
C456 dvdd a_n8227_n26906# 0.36016f
C457 x1.nfet_03v3_EV2W8D_0.S1 x1.xtr.top 0.17969f
C458 gf180mcu_ocd_ip__classab_buffer_0.se_folded_cascode_np_ab_0.vbn1 gf180mcu_ocd_ip__classab_buffer_0.se_folded_cascode_np_ab_0.outa1n 0.01372f
C459 x1.pnp_05p00x05p00_0_0[0|0].E x1.xtr.nfet_03v3_GP977X_0.S11 0.1624f
C460 gf180mcu_ocd_ip__classab_buffer_0.se_folded_cascode_np_ab_0.vbn2 gf180mcu_ocd_ip__classab_buffer_0.se_folded_cascode_np_ab_0.outa1p 2.71113f
C461 x1.pfet_03v3_73PQE5_0.S0 x1.pnp_05p00x05p00_0_0[0|0].E 0.0119f
C462 x1.pnp_05p00x05p00_0_0[0|0].E x1.pfet_03v3_BWTVHK_0.D 20.1744f
C463 trim[2] a_n8227_n27802# 0.25468f
C464 trim[3] trim[2] 0.02212f
C465 x1.gf180mcu_as_sc_mcu7t3v3__buff_2_10.Y x1.gf180mcu_as_sc_mcu7t3v3__buff_2_11.Y 0.21103f
C466 x1.pnp_05p00x05p00_0_0[0|0].E x1.xtr.nfet_03v3_GP977X_0.S13 0.16043f
C467 x1.gf180mcu_as_sc_mcu7t3v3__buff_2_8.Y x1.gf180mcu_as_sc_mcu7t3v3__buff_2_7.Y 0.23816f
C468 x1.nfet_03v3_EV2W8D_0.S1 x1.xtr.nfet_03v3_GP977X_0.S10 0.01967f
C469 gf180mcu_ocd_ip__classab_buffer_0.se_folded_cascode_np_ab_0.diffb gf180mcu_ocd_ip__classab_buffer_0.se_folded_cascode_np_ab_0.vbp1 2.37406f
C470 x1.gf180mcu_as_sc_mcu7t3v3__buff_2_15.Y x1.gf180mcu_as_sc_mcu7t3v3__buff_2_14.Y 0.2036f
C471 a_n3700_n18719# x1.nfet_03v3_EV2W8D_0.S1 0.0715f
C472 dvdd x1.gf180mcu_as_sc_mcu7t3v3__buff_2_4.Y 0.16654f
C473 dvdd x1.gf180mcu_as_sc_mcu7t3v3__buff_2_6.Y 0.16602f
C474 x1.xtr.nfet_03v3_GP977X_0.S8 x1.gf180mcu_as_sc_mcu7t3v3__buff_2_7.Y 0.03962f
C475 dvdd gf180mcu_ocd_ip__classab_buffer_0.se_folded_cascode_np_ab_0.outa1p 9.16883f
C476 x1.nfet_03v3_EV2W8D_0.S0 x1.pfet_03v3_BWTVHK_0.D 0.29461f
C477 trim[6] trim[5] 0.02213f
C478 dvdd gf180mcu_ocd_ip__classab_buffer_0.se_folded_cascode_np_ab_0.nfet_03v3_XRMCLC_0.S0_0 0.14013f
C479 trim[2] x1.gf180mcu_as_sc_mcu7t3v3__buff_2_3.Y 0.02413f
C480 ibias2_1u gf180mcu_ocd_ip__classab_buffer_0.se_folded_cascode_np_ab_0.outb1p 0.04562f
C481 dvdd a_n8227_n24218# 0.36016f
C482 dvdd a_n8227_n26010# 0.36016f
C483 gf180mcu_ocd_ip__classab_buffer_0.se_folded_cascode_np_ab_0.outb1n gf180mcu_ocd_ip__classab_buffer_0.se_folded_cascode_np_ab_0.outb1p 23.4157f
C484 a_n3700_n16199# a_n3700_n16479# 0.29949f
C485 gf180mcu_ocd_ip__classab_buffer_0.se_folded_cascode_np_ab_0.diffb x1.ena_buf 0.4232f
C486 gf180mcu_ocd_ip__classab_buffer_0.se_folded_cascode_np_ab_0.nfet_03v3_XHQ8ZW_0.S0_0 gf180mcu_ocd_ip__classab_buffer_0.se_folded_cascode_np_ab_0.outb1p 0.0148f
C487 a_n3700_n19839# a_n3700_n20679# 0.02567f
C488 dvdd dvss 0.49193p
C489 gf180mcu_ocd_ip__classab_buffer_0.se_folded_cascode_np_ab_0.nfet_03v3_XRMCLC_0.S0_0 dvss 13.99798f
C490 gf180mcu_ocd_ip__classab_buffer_0.se_folded_cascode_np_ab_0.nfet_03v3_XHQ8ZW_0.S0_0 dvss 20.25085f
C491 gf180mcu_ocd_ip__classab_buffer_0.se_folded_cascode_np_ab_0.outb1n dvss 10.58342f
C492 gf180mcu_ocd_ip__classab_buffer_0.se_folded_cascode_np_ab_0.outb1p dvss 44.07806f
C493 gf180mcu_ocd_ip__classab_buffer_0.se_folded_cascode_np_ab_0.pfet_03v3_XWLNX2_0.D dvss 49.28797f
C494 gf180mcu_ocd_ip__classab_buffer_0.se_folded_cascode_np_ab_0.outa1p dvss 18.82316f
C495 gf180mcu_ocd_ip__classab_buffer_0.se_folded_cascode_np_ab_0.diffb dvss 2.23159f
C496 gf180mcu_ocd_ip__classab_buffer_0.se_folded_cascode_np_ab_0.outa1n dvss 16.89251f
C497 x1.xamp.pfet_03v3_VL4T3E_0.S1_0 dvss 11.66313f
C498 x1.xamp.pfet_03v3_EQVFPB_0.S1_0 dvss 6.96424f
C499 x1.xamp.pfet_03v3_EQVFPB_0.S1_1 dvss 6.84688f
C500 x1.xamp.vbp1 dvss 5.1312f
C501 x1.xamp.pfet_03v3_EQVFPB_0.G1_0 dvss 15.76548f
C502 x1.xamp.out1n dvss 14.07443f
C503 x1.xamp.out1p dvss 23.90561f
C504 x1.nfet_03v3_EV2W8D_0.S1 dvss 17.74871f
C505 x1.nfet_03v3_EV2W8D_0.S0 dvss 0.18576f
C506 x1.pfet_03v3_73PQE5_0.S0 dvss 0.59241f
C507 a_n3700_n22079# dvss 0.54548f
C508 a_n3700_n21799# dvss 0.83402f
C509 a_n598_n21519# dvss 0.83384f
C510 a_n598_n21239# dvss 0.51753f
C511 a_n3700_n20959# dvss 0.51221f
C512 a_n3700_n20679# dvss 0.82901f
C513 a_n598_n20399# dvss 0.83912f
C514 a_n598_n20119# dvss 0.53052f
C515 a_n3700_n19839# dvss 0.53948f
C516 a_n3700_n19559# dvss 0.84336f
C517 a_n598_n19279# dvss 0.84417f
C518 a_n598_n18999# dvss 0.51319f
C519 a_n3700_n18719# dvss 0.51341f
C520 a_n3700_n18439# dvss 0.82793f
C521 a_n598_n18159# dvss 0.82892f
C522 a_n598_n17879# dvss 0.51242f
C523 a_n3700_n17599# dvss 0.51161f
C524 a_n3700_n17319# dvss 0.82788f
C525 a_n598_n17039# dvss 0.83517f
C526 a_n598_n16759# dvss 0.51653f
C527 x1.pnp_05p00x05p00_0_0[1|1].E dvss 0.26525f
C528 a_n3700_n16479# dvss 0.51715f
C529 a_n3700_n16199# dvss 0.83343f
C530 x1.xtr.nfet_03v3_GP977X_0.S15 dvss 3.3442f
C531 x1.xtr.nfet_03v3_GP977X_0.S14 dvss 3.2531f
C532 x1.xtr.nfet_03v3_GP977X_0.S13 dvss 3.238f
C533 x1.xtr.nfet_03v3_GP977X_0.S12 dvss 3.10764f
C534 x1.xtr.nfet_03v3_GP977X_0.S11 dvss 3.20088f
C535 x1.xtr.nfet_03v3_GP977X_0.S10 dvss 3.20524f
C536 x1.xtr.nfet_03v3_GP977X_0.S9 dvss 3.2049f
C537 x1.xtr.nfet_03v3_GP977X_0.S8 dvss 3.18824f
C538 x1.xtr.nfet_03v3_GP977X_0.S7 dvss 3.19595f
C539 x1.xtr.nfet_03v3_GP977X_0.S6 dvss 3.15401f
C540 x1.xtr.nfet_03v3_GP977X_0.S5 dvss 3.19157f
C541 x1.xtr.nfet_03v3_GP977X_0.S4 dvss 3.18736f
C542 x1.xtr.nfet_03v3_GP977X_0.S3 dvss 3.17826f
C543 x1.xtr.nfet_03v3_GP977X_0.S2 dvss 3.1359f
C544 x1.xtr.nfet_03v3_GP977X_0.S1 dvss 3.1716f
C545 x1.xtr.top dvss 7.12177f
C546 x1.pnp_05p00x05p00_0_0[0|0].E dvss 58.89491f
C547 x1.gf180mcu_as_sc_mcu7t3v3__buff_2_3.Y dvss 0.25507f
C548 x1.gf180mcu_as_sc_mcu7t3v3__buff_2_7.Y dvss 0.08028f
C549 x1.gf180mcu_as_sc_mcu7t3v3__buff_2_9.Y dvss 0.07869f
C550 x1.gf180mcu_as_sc_mcu7t3v3__buff_2_13.Y dvss 0.07889f
C551 x1.pnp_05p00x05p00_0_0[0|0].E.n0 dvss 0.39013f
C552 x1.pnp_05p00x05p00_0_0[0|0].E.n1 dvss 0.71318f
C553 x1.pnp_05p00x05p00_0_0[0|0].E.n2 dvss 0.50355f
C554 x1.pnp_05p00x05p00_0_0[0|0].E.n3 dvss 0.33448f
C555 x1.pnp_05p00x05p00_0_0[0|0].E.n4 dvss 0.3761f
C556 x1.pnp_05p00x05p00_0_0[0|0].E.n5 dvss 0.51778f
C557 x1.pnp_05p00x05p00_0_0[0|0].E.n6 dvss 0.72395f
C558 x1.pnp_05p00x05p00_0_0[0|0].E.n7 dvss 0.7142f
C559 x1.pnp_05p00x05p00_0_0[0|0].E.n8 dvss 0.713f
C560 x1.pnp_05p00x05p00_0_0[0|0].E.n9 dvss 0.7142f
C561 x1.pnp_05p00x05p00_0_0[0|0].E.n10 dvss 0.75612f
C562 x1.pnp_05p00x05p00_0_0[0|0].E.n11 dvss 0.41199f
C563 x1.pnp_05p00x05p00_0_0[0|0].E.n12 dvss 0.07055f
C564 x1.pnp_05p00x05p00_0_0[0|0].E.t27 dvss 0.64311f
C565 x1.pnp_05p00x05p00_0_0[0|0].E.n13 dvss 0.16812f
C566 x1.pnp_05p00x05p00_0_0[0|0].E.t26 dvss 0.56975f
C567 x1.pnp_05p00x05p00_0_0[0|0].E.n14 dvss 0.13726f
C568 x1.pnp_05p00x05p00_0_0[0|0].E.t29 dvss 0.53576f
C569 x1.pnp_05p00x05p00_0_0[0|0].E.n15 dvss 0.13726f
C570 x1.pnp_05p00x05p00_0_0[0|0].E.t28 dvss 0.58088f
C571 x1.pnp_05p00x05p00_0_0[0|0].E.n16 dvss 0.13724f
C572 x1.pnp_05p00x05p00_0_0[0|0].E.t4 dvss 0.59139f
C573 x1.pnp_05p00x05p00_0_0[0|0].E.n17 dvss 0.13726f
C574 x1.pnp_05p00x05p00_0_0[0|0].E.t3 dvss 0.59777f
C575 x1.pnp_05p00x05p00_0_0[0|0].E.n18 dvss 0.13726f
C576 x1.pnp_05p00x05p00_0_0[0|0].E.t2 dvss 0.5594f
C577 x1.pnp_05p00x05p00_0_0[0|0].E.n19 dvss 0.13726f
C578 x1.pnp_05p00x05p00_0_0[0|0].E.t1 dvss 0.60145f
C579 x1.pnp_05p00x05p00_0_0[0|0].E.n20 dvss 0.13724f
C580 x1.pnp_05p00x05p00_0_0[0|0].E.t0 dvss 0.59145f
C581 x1.pnp_05p00x05p00_0_0[0|0].E.n21 dvss 0.13726f
C582 x1.pnp_05p00x05p00_0_0[0|0].E.t20 dvss 0.61253f
C583 x1.pnp_05p00x05p00_0_0[0|0].E.n22 dvss 0.13726f
C584 x1.pnp_05p00x05p00_0_0[0|0].E.t31 dvss 0.61644f
C585 x1.pnp_05p00x05p00_0_0[0|0].E.n23 dvss 0.13726f
C586 x1.pnp_05p00x05p00_0_0[0|0].E.t30 dvss 0.61656f
C587 x1.pnp_05p00x05p00_0_0[0|0].E.n24 dvss 0.13726f
C588 x1.pnp_05p00x05p00_0_0[0|0].E.t21 dvss 0.49066f
C589 x1.pnp_05p00x05p00_0_0[0|0].E.n25 dvss 0.13726f
C590 x1.pnp_05p00x05p00_0_0[0|0].E.t11 dvss 0.61823f
C591 x1.pnp_05p00x05p00_0_0[0|0].E.n26 dvss 0.13726f
C592 x1.pnp_05p00x05p00_0_0[0|0].E.t10 dvss 0.63366f
C593 x1.pnp_05p00x05p00_0_0[0|0].E.n27 dvss 0.13726f
C594 x1.pnp_05p00x05p00_0_0[0|0].E.t25 dvss 0.71896f
C595 x1.pnp_05p00x05p00_0_0[0|0].E.n28 dvss 0.11697f
C596 x1.pnp_05p00x05p00_0_0[0|0].E.n29 dvss 0.18404f
C597 x1.pnp_05p00x05p00_0_0[0|0].E.n30 dvss 0.07193f
C598 x1.pnp_05p00x05p00_0_0[0|0].E.n31 dvss 0.03584f
C599 x1.pnp_05p00x05p00_0_0[0|0].E.n32 dvss 0.03598f
C600 x1.pnp_05p00x05p00_0_0[0|0].E.t24 dvss 0.06645f
C601 x1.pnp_05p00x05p00_0_0[0|0].E.n33 dvss 0.10137f
C602 x1.pnp_05p00x05p00_0_0[0|0].E.n34 dvss 0.23131f
C603 x1.pnp_05p00x05p00_0_0[0|0].E.n35 dvss 0.85976f
C604 x1.pnp_05p00x05p00_0_0[0|0].E.n36 dvss 0.87113f
C605 x1.pnp_05p00x05p00_0_0[0|0].E.n37 dvss 0.33698f
C606 x1.pnp_05p00x05p00_0_0[0|0].E.n38 dvss 0.35072f
C607 x1.pnp_05p00x05p00_0_0[0|0].E.n39 dvss 0.17629f
C608 x1.pnp_05p00x05p00_0_0[0|0].E.t9 dvss 0.01681f
C609 x1.pnp_05p00x05p00_0_0[0|0].E.t5 dvss 0.01565f
C610 x1.pnp_05p00x05p00_0_0[0|0].E.t32 dvss 0.01565f
C611 x1.pnp_05p00x05p00_0_0[0|0].E.t6 dvss 0.01687f
C612 x1.pnp_05p00x05p00_0_0[0|0].E.t8 dvss 0.01565f
C613 x1.pnp_05p00x05p00_0_0[0|0].E.t7 dvss 0.01565f
C614 x1.pnp_05p00x05p00_0_0[0|0].E.n40 dvss 0.07204f
C615 x1.pnp_05p00x05p00_0_0[0|0].E.t23 dvss 0.04299f
C616 x1.nfet_03v3_EV2W8D_0.S1.n0 dvss 0.07665f
C617 x1.nfet_03v3_EV2W8D_0.S1.n1 dvss 0.23423f
C618 x1.nfet_03v3_EV2W8D_0.S1.n2 dvss 0.82888f
C619 x1.nfet_03v3_EV2W8D_0.S1.n3 dvss 0.0351f
C620 x1.nfet_03v3_EV2W8D_0.S1.n4 dvss 0.06095f
C621 x1.nfet_03v3_EV2W8D_0.S1.n5 dvss 0.02809f
C622 x1.nfet_03v3_EV2W8D_0.S1.t20 dvss 0.01497f
C623 x1.nfet_03v3_EV2W8D_0.S1.n6 dvss 0.05653f
C624 x1.nfet_03v3_EV2W8D_0.S1.n7 dvss 0.02848f
C625 x1.nfet_03v3_EV2W8D_0.S1.t18 dvss 0.01497f
C626 x1.nfet_03v3_EV2W8D_0.S1.n8 dvss 0.04784f
C627 x1.nfet_03v3_EV2W8D_0.S1.n9 dvss 0.02809f
C628 x1.nfet_03v3_EV2W8D_0.S1.t17 dvss 0.01497f
C629 x1.nfet_03v3_EV2W8D_0.S1.n10 dvss 0.05704f
C630 x1.nfet_03v3_EV2W8D_0.S1.n11 dvss 0.02848f
C631 x1.nfet_03v3_EV2W8D_0.S1.t15 dvss 0.01497f
C632 x1.nfet_03v3_EV2W8D_0.S1.n12 dvss 0.0488f
C633 x1.nfet_03v3_EV2W8D_0.S1.n13 dvss 0.02809f
C634 x1.nfet_03v3_EV2W8D_0.S1.t14 dvss 0.01497f
C635 x1.nfet_03v3_EV2W8D_0.S1.n14 dvss 0.05804f
C636 x1.nfet_03v3_EV2W8D_0.S1.t0 dvss 11.20754f
C637 x1.nfet_03v3_EV2W8D_0.S1.t12 dvss 0.01497f
C638 x1.nfet_03v3_EV2W8D_0.S1.n15 dvss 0.05069f
C639 x1.nfet_03v3_EV2W8D_0.S1.t19 dvss 0.01497f
C640 x1.nfet_03v3_EV2W8D_0.S1.n16 dvss 0.03847f
C641 x1.nfet_03v3_EV2W8D_0.S1.n17 dvss 0.03495f
C642 x1.nfet_03v3_EV2W8D_0.S1.n18 dvss 0.0351f
C643 x1.nfet_03v3_EV2W8D_0.S1.t16 dvss 0.01497f
C644 x1.nfet_03v3_EV2W8D_0.S1.n19 dvss 0.03872f
C645 x1.nfet_03v3_EV2W8D_0.S1.n20 dvss 0.03511f
C646 x1.nfet_03v3_EV2W8D_0.S1.n21 dvss 0.03511f
C647 x1.nfet_03v3_EV2W8D_0.S1.t13 dvss 0.01497f
C648 x1.nfet_03v3_EV2W8D_0.S1.n22 dvss 0.03857f
C649 x1.nfet_03v3_EV2W8D_0.S1.n23 dvss 0.03526f
C650 x1.nfet_03v3_EV2W8D_0.S1.t11 dvss 0.01497f
C651 x1.nfet_03v3_EV2W8D_0.S1.n24 dvss 0.03893f
C652 x1.nfet_03v3_EV2W8D_0.S1.t10 dvss 0.01497f
C653 x1.nfet_03v3_EV2W8D_0.S1.n25 dvss 0.03857f
C654 x1.nfet_03v3_EV2W8D_0.S1.t9 dvss 0.01497f
C655 x1.nfet_03v3_EV2W8D_0.S1.n26 dvss 0.03878f
C656 x1.nfet_03v3_EV2W8D_0.S1.t8 dvss 0.01497f
C657 x1.nfet_03v3_EV2W8D_0.S1.n27 dvss 0.09017f
C658 x1.nfet_03v3_EV2W8D_0.S1.t24 dvss 0.54025f
C659 x1.nfet_03v3_EV2W8D_0.S1.n29 dvss 0.29509f
C660 x1.nfet_03v3_EV2W8D_0.S1.n30 dvss 0.77386f
C661 x1.nfet_03v3_EV2W8D_0.S1.n31 dvss 0.0848f
C662 x1.nfet_03v3_EV2W8D_0.S1.n32 dvss 0.07604f
C663 x1.nfet_03v3_EV2W8D_0.S1.n33 dvss 0.03058f
C664 x1.nfet_03v3_EV2W8D_0.S1.n34 dvss 0.03959f
C665 x1.nfet_03v3_EV2W8D_0.S1.n35 dvss 0.08458f
C666 x1.nfet_03v3_EV2W8D_0.S1.n36 dvss 0.02738f
C667 x1.nfet_03v3_EV2W8D_0.S1.n37 dvss 0.03659f
C668 x1.nfet_03v3_EV2W8D_0.S1.n38 dvss 0.07489f
C669 x1.nfet_03v3_EV2W8D_0.S1.n39 dvss 0.03058f
C670 x1.nfet_03v3_EV2W8D_0.S1.n40 dvss 0.03959f
C671 x1.nfet_03v3_EV2W8D_0.S1.n41 dvss 0.08376f
C672 x1.nfet_03v3_EV2W8D_0.S1.n42 dvss 0.02738f
C673 x1.nfet_03v3_EV2W8D_0.S1.n43 dvss 0.03659f
C674 x1.nfet_03v3_EV2W8D_0.S1.n44 dvss 0.07403f
C675 x1.nfet_03v3_EV2W8D_0.S1.n45 dvss 0.03058f
C676 x1.nfet_03v3_EV2W8D_0.S1.n46 dvss 0.03959f
C677 x1.nfet_03v3_EV2W8D_0.S1.n47 dvss 0.08288f
C678 x1.nfet_03v3_EV2W8D_0.S1.n48 dvss 0.06207f
C679 x1.nfet_03v3_EV2W8D_0.S1.n49 dvss 0.0891f
C680 x1.nfet_03v3_EV2W8D_0.S1.t21 dvss 0.13233f
C681 x1.nfet_03v3_EV2W8D_0.S1.n50 dvss 0.04701f
C682 x1.nfet_03v3_EV2W8D_0.S1.n51 dvss 0.03526f
C683 x1.nfet_03v3_EV2W8D_0.S1.t22 dvss 0.01497f
C684 x1.nfet_03v3_EV2W8D_0.S1.n52 dvss 0.06334f
C685 x1.nfet_03v3_EV2W8D_0.S1.n53 dvss 0.19685f
C686 x1.nfet_03v3_EV2W8D_0.S1.n55 dvss 0.02749f
C687 x1.xamp.pfet_03v3_EQVFPB_0.G1_0.n0 dvss 0.91936f
C688 x1.xamp.pfet_03v3_EQVFPB_0.G1_0.n1 dvss 0.45369f
C689 x1.xamp.pfet_03v3_EQVFPB_0.G1_0.n2 dvss 0.26605f
C690 x1.xamp.pfet_03v3_EQVFPB_0.G1_0.n3 dvss 0.22885f
C691 x1.xamp.pfet_03v3_EQVFPB_0.G1_0.n4 dvss 0.45993f
C692 x1.xamp.pfet_03v3_EQVFPB_0.G1_0.n5 dvss 0.70235f
C693 x1.xamp.pfet_03v3_EQVFPB_0.G1_0.n6 dvss 0.45838f
C694 x1.xamp.pfet_03v3_EQVFPB_0.G1_0.n7 dvss 0.2745f
C695 x1.xamp.pfet_03v3_EQVFPB_0.G1_0.t23 dvss 0.15214f
C696 x1.xamp.pfet_03v3_EQVFPB_0.G1_0.n8 dvss 0.92688f
C697 x1.xamp.pfet_03v3_EQVFPB_0.G1_0.n10 dvss 0.50083f
C698 x1.xamp.pfet_03v3_EQVFPB_0.G1_0.n11 dvss 0.7557f
C699 x1.xamp.pfet_03v3_EQVFPB_0.G1_0.n12 dvss 0.50083f
C700 x1.xamp.pfet_03v3_EQVFPB_0.G1_0.n13 dvss 0.7507f
C701 x1.xamp.pfet_03v3_EQVFPB_0.G1_0.n14 dvss 0.50083f
C702 x1.xamp.pfet_03v3_EQVFPB_0.G1_0.n15 dvss 0.74484f
C703 x1.xamp.pfet_03v3_EQVFPB_0.G1_0.n16 dvss 0.50083f
C704 x1.xamp.pfet_03v3_EQVFPB_0.G1_0.n17 dvss 0.57414f
C705 x1.xamp.pfet_03v3_EQVFPB_0.G1_0.n18 dvss 0.50083f
C706 x1.xamp.pfet_03v3_EQVFPB_0.G1_0.n19 dvss 0.58664f
C707 x1.xamp.pfet_03v3_EQVFPB_0.G1_0.n20 dvss 0.50081f
C708 x1.xamp.pfet_03v3_EQVFPB_0.G1_0.n21 dvss 0.56657f
C709 x1.xamp.pfet_03v3_EQVFPB_0.G1_0.n22 dvss 0.50083f
C710 x1.xamp.pfet_03v3_EQVFPB_0.G1_0.n23 dvss 0.54043f
C711 x1.xamp.pfet_03v3_EQVFPB_0.G1_0.n24 dvss 0.65425f
C712 x1.xamp.pfet_03v3_EQVFPB_0.G1_0.n25 dvss 0.37387f
C713 x1.xamp.pfet_03v3_EQVFPB_0.G1_0.n26 dvss 0.52655f
C714 x1.xamp.pfet_03v3_EQVFPB_0.G1_0.n27 dvss 0.34518f
C715 x1.xamp.pfet_03v3_EQVFPB_0.G1_0.n28 dvss 0.34518f
C716 x1.xamp.pfet_03v3_EQVFPB_0.G1_0.n29 dvss 0.34249f
C717 x1.xamp.pfet_03v3_EQVFPB_0.G1_0.n30 dvss 0.0313f
C718 x1.xamp.pfet_03v3_EQVFPB_0.G1_0.t20 dvss 0.0979f
C719 x1.xamp.pfet_03v3_EQVFPB_0.G1_0.n31 dvss 0.0313f
C720 x1.xamp.pfet_03v3_EQVFPB_0.G1_0.n32 dvss 0.0313f
C721 x1.xamp.pfet_03v3_EQVFPB_0.G1_0.t17 dvss 0.0979f
C722 x1.xamp.pfet_03v3_EQVFPB_0.G1_0.n33 dvss 0.0313f
C723 x1.xamp.pfet_03v3_EQVFPB_0.G1_0.t3 dvss 0.05812f
C724 x1.xamp.pfet_03v3_EQVFPB_0.G1_0.t16 dvss 0.0979f
C725 x1.xamp.pfet_03v3_EQVFPB_0.G1_0.t2 dvss 0.05812f
C726 x1.xamp.pfet_03v3_EQVFPB_0.G1_0.t15 dvss 0.0979f
C727 x1.xamp.pfet_03v3_EQVFPB_0.G1_0.t1 dvss 0.13342f
C728 x1.xamp.pfet_03v3_EQVFPB_0.G1_0.t13 dvss 0.0979f
C729 x1.xamp.pfet_03v3_EQVFPB_0.G1_0.t0 dvss 0.05812f
C730 x1.xamp.pfet_03v3_EQVFPB_0.G1_0.n34 dvss 0.0313f
C731 x1.xamp.pfet_03v3_EQVFPB_0.G1_0.t8 dvss 0.0979f
C732 x1.xamp.pfet_03v3_EQVFPB_0.G1_0.t9 dvss 0.0979f
C733 x1.xamp.pfet_03v3_EQVFPB_0.G1_0.t10 dvss 0.0979f
C734 x1.xamp.pfet_03v3_EQVFPB_0.G1_0.n35 dvss 0.0313f
C735 x1.xamp.pfet_03v3_EQVFPB_0.G1_0.t11 dvss 0.0979f
C736 x1.xamp.pfet_03v3_EQVFPB_0.G1_0.n36 dvss 0.0313f
C737 x1.xamp.pfet_03v3_EQVFPB_0.G1_0.n37 dvss 0.0313f
C738 x1.xamp.pfet_03v3_EQVFPB_0.G1_0.t14 dvss 0.0979f
C739 x1.xamp.pfet_03v3_EQVFPB_0.G1_0.t12 dvss 0.0979f
C740 x1.xamp.pfet_03v3_EQVFPB_0.G1_0.n38 dvss 0.51265f
C741 x1.xamp.pfet_03v3_EQVFPB_0.G1_0.n39 dvss 0.23487f
C742 x1.xamp.pfet_03v3_EQVFPB_0.G1_0.n40 dvss 0.25776f
C743 x1.xamp.pfet_03v3_EQVFPB_0.G1_0.n41 dvss 0.46291f
C744 x1.xamp.pfet_03v3_EQVFPB_0.G1_0.n42 dvss 0.28215f
C745 x1.xamp.pfet_03v3_EQVFPB_0.G1_0.n43 dvss 0.46414f
C746 x1.xamp.pfet_03v3_EQVFPB_0.G1_0.t4 dvss 0.05812f
C747 x1.xamp.pfet_03v3_EQVFPB_0.G1_0.n44 dvss 0.25776f
C748 x1.xamp.pfet_03v3_EQVFPB_0.G1_0.n45 dvss 0.46848f
C749 x1.xamp.pfet_03v3_EQVFPB_0.G1_0.t5 dvss 0.20873f
C750 x1.xamp.pfet_03v3_EQVFPB_0.G1_0.n46 dvss 0.28215f
C751 x1.xamp.pfet_03v3_EQVFPB_0.G1_0.n47 dvss 0.45905f
C752 x1.xamp.pfet_03v3_EQVFPB_0.G1_0.t18 dvss 0.0979f
C753 x1.xamp.pfet_03v3_EQVFPB_0.G1_0.t19 dvss 0.0979f
C754 x1.xamp.pfet_03v3_EQVFPB_0.G1_0.n48 dvss 0.27764f
C755 x1.xamp.pfet_03v3_EQVFPB_0.G1_0.n49 dvss 0.47382f
C756 x1.xamp.pfet_03v3_EQVFPB_0.G1_0.n50 dvss 0.25776f
C757 x1.xamp.pfet_03v3_EQVFPB_0.G1_0.t6 dvss 0.05812f
C758 x1.xamp.pfet_03v3_EQVFPB_0.G1_0.n51 dvss 0.40247f
C759 x1.xamp.pfet_03v3_EQVFPB_0.G1_0.n52 dvss 0.5557f
C760 x1.xamp.pfet_03v3_EQVFPB_0.G1_0.t21 dvss 0.0979f
C761 x1.xamp.pfet_03v3_EQVFPB_0.G1_0.t7 dvss 0.05812f
C762 x1.xamp.pfet_03v3_EQVFPB_0.G1_0.t22 dvss 0.0979f
C763 x1.xamp.pfet_03v3_EQVFPB_0.G1_0.n53 dvss 1.14069f
C764 x1.xamp.pfet_03v3_EQVFPB_0.G1_0.n54 dvss 0.52447f
C765 x1.xamp.vbp1.t15 dvss 0.17142f
C766 x1.xamp.vbp1.n0 dvss 0.68523f
C767 x1.xamp.vbp1.n1 dvss 0.26186f
C768 x1.xamp.vbp1.n2 dvss 0.31564f
C769 x1.xamp.vbp1.n3 dvss 0.27615f
C770 x1.xamp.vbp1.n4 dvss 0.34726f
C771 x1.xamp.vbp1.n5 dvss 0.18223f
C772 x1.xamp.vbp1.n6 dvss 0.36446f
C773 x1.xamp.vbp1.n7 dvss 0.36446f
C774 x1.xamp.vbp1.n8 dvss 0.68186f
C775 x1.xamp.vbp1.n9 dvss 0.63687f
C776 x1.xamp.vbp1.n10 dvss 0.50087f
C777 x1.xamp.vbp1.n11 dvss 0.36446f
C778 x1.xamp.vbp1.n12 dvss 0.36442f
C779 x1.xamp.vbp1.n13 dvss 0.36442f
C780 x1.xamp.vbp1.n14 dvss 0.36442f
C781 x1.xamp.vbp1.n15 dvss 0.36157f
C782 x1.xamp.vbp1.n17 dvss 0.36157f
C783 x1.xamp.vbp1.n19 dvss 0.36157f
C784 x1.xamp.vbp1.n21 dvss 0.36157f
C785 x1.xamp.vbp1.t12 dvss 0.10905f
C786 x1.xamp.vbp1.t13 dvss 0.10905f
C787 x1.xamp.vbp1.t14 dvss 0.10905f
C788 x1.xamp.vbp1.t11 dvss 0.10905f
C789 x1.xamp.vbp1.t8 dvss 0.10905f
C790 x1.xamp.vbp1.t9 dvss 0.10905f
C791 x1.xamp.vbp1.t10 dvss 0.10905f
C792 x1.xamp.vbp1.n23 dvss 0.26282f
C793 x1.xamp.vbp1.n24 dvss 0.26282f
C794 x1.xamp.vbp1.n25 dvss 0.26282f
C795 x1.xamp.vbp1.n26 dvss 0.26282f
C796 x1.xamp.vbp1.n27 dvss 0.26282f
C797 x1.xamp.vbp1.n28 dvss 0.26282f
C798 x1.xamp.vbp1.n29 dvss 0.26282f
C799 x1.xamp.vbp1.n30 dvss 0.26282f
C800 x1.xamp.vbp1.n31 dvss 0.26282f
C801 x1.xamp.vbp1.n32 dvss 0.12676f
C802 x1.xamp.vbp1.n33 dvss 0.12676f
C803 x1.xamp.vbp1.n34 dvss 0.12676f
C804 x1.xamp.vbp1.n35 dvss 0.12679f
C805 x1.xamp.vbp1.n36 dvss 0.26282f
C806 x1.xamp.vbp1.n37 dvss 0.26282f
C807 x1.xamp.vbp1.n38 dvss 0.26282f
C808 x1.xamp.vbp1.n39 dvss 0.26282f
C809 x1.xamp.vbp1.t7 dvss 0.21749f
C810 x1.xamp.vbp1.n40 dvss 0.26282f
C811 x1.xamp.vbp1.t5 dvss 0.21749f
C812 x1.xamp.vbp1.n41 dvss 0.26282f
C813 x1.xamp.vbp1.t3 dvss 0.21749f
C814 x1.xamp.vbp1.n42 dvss 0.26282f
C815 x1.xamp.vbp1.t1 dvss 0.21749f
C816 gf180mcu_ocd_ip__classab_buffer_0.se_folded_cascode_np_ab_0.outa1n.n0 dvss 0.26991f
C817 gf180mcu_ocd_ip__classab_buffer_0.se_folded_cascode_np_ab_0.outa1n.n1 dvss 1.40269f
C818 gf180mcu_ocd_ip__classab_buffer_0.se_folded_cascode_np_ab_0.outa1n.n2 dvss 1.73176f
C819 gf180mcu_ocd_ip__classab_buffer_0.se_folded_cascode_np_ab_0.outa1n.n3 dvss 1.40518f
C820 gf180mcu_ocd_ip__classab_buffer_0.se_folded_cascode_np_ab_0.outa1n.n4 dvss 2.30874f
C821 gf180mcu_ocd_ip__classab_buffer_0.se_folded_cascode_np_ab_0.outa1n.n5 dvss 2.13003f
C822 gf180mcu_ocd_ip__classab_buffer_0.se_folded_cascode_np_ab_0.outa1n.n6 dvss 0.94284f
C823 gf180mcu_ocd_ip__classab_buffer_0.se_folded_cascode_np_ab_0.outa1n.n7 dvss 0.89482f
C824 gf180mcu_ocd_ip__classab_buffer_0.se_folded_cascode_np_ab_0.outa1n.n8 dvss 0.65853f
C825 gf180mcu_ocd_ip__classab_buffer_0.se_folded_cascode_np_ab_0.outa1n.n9 dvss 0.98859f
C826 gf180mcu_ocd_ip__classab_buffer_0.se_folded_cascode_np_ab_0.outa1n.n10 dvss 0.44453f
C827 gf180mcu_ocd_ip__classab_buffer_0.se_folded_cascode_np_ab_0.outa1n.n11 dvss 0.30293f
C828 gf180mcu_ocd_ip__classab_buffer_0.se_folded_cascode_np_ab_0.outa1n.n12 dvss 0.55918f
C829 gf180mcu_ocd_ip__classab_buffer_0.se_folded_cascode_np_ab_0.outa1n.n13 dvss 0.30293f
C830 gf180mcu_ocd_ip__classab_buffer_0.se_folded_cascode_np_ab_0.outa1n.n14 dvss 0.271f
C831 gf180mcu_ocd_ip__classab_buffer_0.se_folded_cascode_np_ab_0.outa1n.n15 dvss 0.30293f
C832 gf180mcu_ocd_ip__classab_buffer_0.se_folded_cascode_np_ab_0.outa1n.n16 dvss 0.30293f
C833 gf180mcu_ocd_ip__classab_buffer_0.se_folded_cascode_np_ab_0.outa1n.n17 dvss 0.73446f
C834 gf180mcu_ocd_ip__classab_buffer_0.se_folded_cascode_np_ab_0.outa1n.n18 dvss 0.30293f
C835 gf180mcu_ocd_ip__classab_buffer_0.se_folded_cascode_np_ab_0.outa1n.n19 dvss 0.42139f
C836 gf180mcu_ocd_ip__classab_buffer_0.se_folded_cascode_np_ab_0.outa1n.n20 dvss 0.30021f
C837 gf180mcu_ocd_ip__classab_buffer_0.se_folded_cascode_np_ab_0.outa1n.n21 dvss 0.33421f
C838 gf180mcu_ocd_ip__classab_buffer_0.se_folded_cascode_np_ab_0.outa1n.n22 dvss 0.30192f
C839 gf180mcu_ocd_ip__classab_buffer_0.se_folded_cascode_np_ab_0.outa1n.n23 dvss 0.70941f
C840 gf180mcu_ocd_ip__classab_buffer_0.se_folded_cascode_np_ab_0.outa1n.n24 dvss 1.15653f
C841 gf180mcu_ocd_ip__classab_buffer_0.se_folded_cascode_np_ab_0.outa1n.n25 dvss 2.25191f
C842 gf180mcu_ocd_ip__classab_buffer_0.se_folded_cascode_np_ab_0.outa1n.n26 dvss 2.25467f
C843 gf180mcu_ocd_ip__classab_buffer_0.se_folded_cascode_np_ab_0.outa1n.n27 dvss 0.54506f
C844 gf180mcu_ocd_ip__classab_buffer_0.se_folded_cascode_np_ab_0.outa1n.n28 dvss 0.53044f
C845 gf180mcu_ocd_ip__classab_buffer_0.se_folded_cascode_np_ab_0.outa1n.n29 dvss 0.65585f
C846 gf180mcu_ocd_ip__classab_buffer_0.se_folded_cascode_np_ab_0.outa1n.n30 dvss 1.384f
C847 gf180mcu_ocd_ip__classab_buffer_0.se_folded_cascode_np_ab_0.outa1n.n31 dvss 0.72014f
C848 gf180mcu_ocd_ip__classab_buffer_0.se_folded_cascode_np_ab_0.outa1n.n32 dvss 0.71486f
C849 gf180mcu_ocd_ip__classab_buffer_0.se_folded_cascode_np_ab_0.outa1n.n33 dvss 1.21309f
C850 gf180mcu_ocd_ip__classab_buffer_0.se_folded_cascode_np_ab_0.outa1n.n34 dvss 0.43809f
C851 gf180mcu_ocd_ip__classab_buffer_0.se_folded_cascode_np_ab_0.outa1n.n35 dvss 0.43809f
C852 gf180mcu_ocd_ip__classab_buffer_0.se_folded_cascode_np_ab_0.outa1n.n36 dvss 0.44453f
C853 gf180mcu_ocd_ip__classab_buffer_0.se_folded_cascode_np_ab_0.outa1n.n37 dvss 0.44453f
C854 gf180mcu_ocd_ip__classab_buffer_0.se_folded_cascode_np_ab_0.outa1n.n38 dvss 0.44465f
C855 gf180mcu_ocd_ip__classab_buffer_0.se_folded_cascode_np_ab_0.outa1n.n39 dvss 0.30192f
C856 gf180mcu_ocd_ip__classab_buffer_0.se_folded_cascode_np_ab_0.outa1n.n40 dvss 0.44465f
C857 gf180mcu_ocd_ip__classab_buffer_0.se_folded_cascode_np_ab_0.outa1n.n41 dvss 0.90139f
C858 gf180mcu_ocd_ip__classab_buffer_0.se_folded_cascode_np_ab_0.outa1n.n42 dvss 0.44479f
C859 gf180mcu_ocd_ip__classab_buffer_0.se_folded_cascode_np_ab_0.outa1n.n43 dvss 0.44479f
C860 gf180mcu_ocd_ip__classab_buffer_0.se_folded_cascode_np_ab_0.outa1n.n44 dvss 0.44479f
C861 gf180mcu_ocd_ip__classab_buffer_0.se_folded_cascode_np_ab_0.outa1n.n45 dvss 0.52501f
C862 gf180mcu_ocd_ip__classab_buffer_0.se_folded_cascode_np_ab_0.outa1n.n46 dvss 1.50783f
C863 gf180mcu_ocd_ip__classab_buffer_0.se_folded_cascode_np_ab_0.outa1n.n47 dvss 0.57838f
C864 gf180mcu_ocd_ip__classab_buffer_0.se_folded_cascode_np_ab_0.outa1n.n48 dvss 0.0138f
C865 gf180mcu_ocd_ip__classab_buffer_0.se_folded_cascode_np_ab_0.outa1n.t17 dvss 0.2485f
C866 gf180mcu_ocd_ip__classab_buffer_0.se_folded_cascode_np_ab_0.outa1n.t19 dvss 0.2485f
C867 gf180mcu_ocd_ip__classab_buffer_0.se_folded_cascode_np_ab_0.outa1n.n49 dvss 0.02254f
C868 gf180mcu_ocd_ip__classab_buffer_0.se_folded_cascode_np_ab_0.outa1n.n50 dvss 0.46358f
C869 gf180mcu_ocd_ip__classab_buffer_0.se_folded_cascode_np_ab_0.outa1n.n51 dvss 0.01732f
C870 gf180mcu_ocd_ip__classab_buffer_0.se_folded_cascode_np_ab_0.outa1n.t1 dvss 0.07543f
C871 gf180mcu_ocd_ip__classab_buffer_0.se_folded_cascode_np_ab_0.outa1n.n52 dvss 0.01347f
C872 gf180mcu_ocd_ip__classab_buffer_0.se_folded_cascode_np_ab_0.outa1n.t21 dvss 0.2485f
C873 gf180mcu_ocd_ip__classab_buffer_0.se_folded_cascode_np_ab_0.outa1n.t5 dvss 0.07543f
C874 gf180mcu_ocd_ip__classab_buffer_0.se_folded_cascode_np_ab_0.outa1n.t8 dvss 0.07543f
C875 gf180mcu_ocd_ip__classab_buffer_0.se_folded_cascode_np_ab_0.outa1n.t14 dvss 0.07543f
C876 gf180mcu_ocd_ip__classab_buffer_0.se_folded_cascode_np_ab_0.outa1n.t11 dvss 0.07543f
C877 gf180mcu_ocd_ip__classab_buffer_0.se_folded_cascode_np_ab_0.outa1n.t15 dvss 0.07543f
C878 gf180mcu_ocd_ip__classab_buffer_0.se_folded_cascode_np_ab_0.outa1n.n53 dvss 0.01808f
C879 gf180mcu_ocd_ip__classab_buffer_0.se_folded_cascode_np_ab_0.outa1n.n54 dvss 0.02455f
C880 gf180mcu_ocd_ip__classab_buffer_0.se_folded_cascode_np_ab_0.outa1n.n55 dvss 0.19934f
C881 gf180mcu_ocd_ip__classab_buffer_0.se_folded_cascode_np_ab_0.outa1n.t39 dvss 0.2485f
C882 gf180mcu_ocd_ip__classab_buffer_0.se_folded_cascode_np_ab_0.outa1n.n56 dvss 0.02618f
C883 gf180mcu_ocd_ip__classab_buffer_0.se_folded_cascode_np_ab_0.outa1n.n57 dvss 0.45791f
C884 gf180mcu_ocd_ip__classab_buffer_0.se_folded_cascode_np_ab_0.outa1n.n58 dvss 0.17767f
C885 gf180mcu_ocd_ip__classab_buffer_0.se_folded_cascode_np_ab_0.outa1n.t37 dvss 0.2485f
C886 gf180mcu_ocd_ip__classab_buffer_0.se_folded_cascode_np_ab_0.outa1n.n59 dvss 0.0161f
C887 gf180mcu_ocd_ip__classab_buffer_0.se_folded_cascode_np_ab_0.outa1n.n60 dvss 0.52778f
C888 gf180mcu_ocd_ip__classab_buffer_0.se_folded_cascode_np_ab_0.outa1n.n61 dvss 0.17767f
C889 gf180mcu_ocd_ip__classab_buffer_0.se_folded_cascode_np_ab_0.outa1n.n62 dvss 0.01315f
C890 gf180mcu_ocd_ip__classab_buffer_0.se_folded_cascode_np_ab_0.outa1n.t35 dvss 0.2485f
C891 gf180mcu_ocd_ip__classab_buffer_0.se_folded_cascode_np_ab_0.outa1n.n63 dvss 0.17594f
C892 gf180mcu_ocd_ip__classab_buffer_0.se_folded_cascode_np_ab_0.outa1n.t33 dvss 0.2485f
C893 gf180mcu_ocd_ip__classab_buffer_0.se_folded_cascode_np_ab_0.outa1n.n64 dvss 0.02408f
C894 gf180mcu_ocd_ip__classab_buffer_0.se_folded_cascode_np_ab_0.outa1n.n65 dvss 0.4588f
C895 gf180mcu_ocd_ip__classab_buffer_0.se_folded_cascode_np_ab_0.outa1n.t31 dvss 0.2485f
C896 gf180mcu_ocd_ip__classab_buffer_0.se_folded_cascode_np_ab_0.outa1n.n66 dvss 0.02377f
C897 gf180mcu_ocd_ip__classab_buffer_0.se_folded_cascode_np_ab_0.outa1n.n67 dvss 0.45923f
C898 gf180mcu_ocd_ip__classab_buffer_0.se_folded_cascode_np_ab_0.outa1n.n68 dvss 0.17767f
C899 gf180mcu_ocd_ip__classab_buffer_0.se_folded_cascode_np_ab_0.outa1n.n69 dvss 0.17767f
C900 gf180mcu_ocd_ip__classab_buffer_0.se_folded_cascode_np_ab_0.outa1n.t23 dvss 0.2485f
C901 gf180mcu_ocd_ip__classab_buffer_0.se_folded_cascode_np_ab_0.outa1n.n70 dvss 0.01315f
C902 gf180mcu_ocd_ip__classab_buffer_0.se_folded_cascode_np_ab_0.outa1n.n71 dvss 0.17767f
C903 gf180mcu_ocd_ip__classab_buffer_0.se_folded_cascode_np_ab_0.outa1n.t25 dvss 0.2485f
C904 gf180mcu_ocd_ip__classab_buffer_0.se_folded_cascode_np_ab_0.outa1n.t6 dvss 0.07543f
C905 gf180mcu_ocd_ip__classab_buffer_0.se_folded_cascode_np_ab_0.outa1n.n72 dvss 0.30192f
C906 gf180mcu_ocd_ip__classab_buffer_0.se_folded_cascode_np_ab_0.outa1n.t2 dvss 0.07543f
C907 gf180mcu_ocd_ip__classab_buffer_0.se_folded_cascode_np_ab_0.outa1n.n73 dvss 0.30192f
C908 gf180mcu_ocd_ip__classab_buffer_0.se_folded_cascode_np_ab_0.outa1n.n74 dvss 0.0224f
C909 gf180mcu_ocd_ip__classab_buffer_0.se_folded_cascode_np_ab_0.outa1n.n75 dvss 0.17767f
C910 gf180mcu_ocd_ip__classab_buffer_0.se_folded_cascode_np_ab_0.outa1n.t27 dvss 0.2485f
C911 gf180mcu_ocd_ip__classab_buffer_0.se_folded_cascode_np_ab_0.outa1n.n76 dvss 0.02f
C912 gf180mcu_ocd_ip__classab_buffer_0.se_folded_cascode_np_ab_0.outa1n.n77 dvss 0.17767f
C913 gf180mcu_ocd_ip__classab_buffer_0.se_folded_cascode_np_ab_0.outa1n.t29 dvss 0.2485f
C914 gf180mcu_ocd_ip__classab_buffer_0.se_folded_cascode_np_ab_0.outa1n.n78 dvss 0.02364f
C915 gf180mcu_ocd_ip__classab_buffer_0.se_folded_cascode_np_ab_0.outa1n.n79 dvss 0.45929f
C916 gf180mcu_ocd_ip__classab_buffer_0.se_folded_cascode_np_ab_0.outa1n.t3 dvss 0.07543f
C917 gf180mcu_ocd_ip__classab_buffer_0.se_folded_cascode_np_ab_0.outa1n.n80 dvss 0.76f
C918 gf180mcu_ocd_ip__classab_buffer_0.se_folded_cascode_np_ab_0.outa1n.t7 dvss 0.07543f
C919 gf180mcu_ocd_ip__classab_buffer_0.se_folded_cascode_np_ab_0.outa1n.n81 dvss 0.76f
C920 gf180mcu_ocd_ip__classab_buffer_0.se_folded_cascode_np_ab_0.outa1n.n82 dvss 0.27023f
C921 gf180mcu_ocd_ip__classab_buffer_0.se_folded_cascode_np_ab_0.outa1n.n83 dvss 0.30158f
C922 gf180mcu_ocd_ip__classab_buffer_0.se_folded_cascode_np_ab_0.outa1n.t10 dvss 0.07543f
C923 gf180mcu_ocd_ip__classab_buffer_0.se_folded_cascode_np_ab_0.outa1n.n84 dvss 0.30192f
C924 gf180mcu_ocd_ip__classab_buffer_0.se_folded_cascode_np_ab_0.outa1n.n85 dvss 0.26972f
C925 gf180mcu_ocd_ip__classab_buffer_0.se_folded_cascode_np_ab_0.outa1n.t13 dvss 0.07543f
C926 gf180mcu_ocd_ip__classab_buffer_0.se_folded_cascode_np_ab_0.outa1n.n86 dvss 0.30158f
C927 gf180mcu_ocd_ip__classab_buffer_0.se_folded_cascode_np_ab_0.outa1n.n87 dvss 0.26803f
C928 gf180mcu_ocd_ip__classab_buffer_0.se_folded_cascode_np_ab_0.outa1n.n88 dvss 0.30158f
C929 gf180mcu_ocd_ip__classab_buffer_0.se_folded_cascode_np_ab_0.outa1n.t12 dvss 0.07543f
C930 gf180mcu_ocd_ip__classab_buffer_0.se_folded_cascode_np_ab_0.outa1n.n89 dvss 0.49078f
C931 gf180mcu_ocd_ip__classab_buffer_0.se_folded_cascode_np_ab_0.outa1n.n90 dvss 0.45191f
C932 gf180mcu_ocd_ip__classab_buffer_0.se_folded_cascode_np_ab_0.outa1n.t9 dvss 0.07543f
C933 gf180mcu_ocd_ip__classab_buffer_0.se_folded_cascode_np_ab_0.outa1n.n91 dvss 0.30192f
C934 gf180mcu_ocd_ip__classab_buffer_0.se_folded_cascode_np_ab_0.outa1n.t4 dvss 0.07543f
C935 gf180mcu_ocd_ip__classab_buffer_0.se_folded_cascode_np_ab_0.outa1n.n92 dvss 0.49756f
C936 gf180mcu_ocd_ip__classab_buffer_0.se_folded_cascode_np_ab_0.outa1n.n93 dvss 0.30192f
C937 gf180mcu_ocd_ip__classab_buffer_0.se_folded_cascode_np_ab_0.outa1n.t0 dvss 0.07543f
C938 gf180mcu_ocd_ip__classab_buffer_0.se_folded_cascode_np_ab_0.outa1n.n94 dvss 0.45229f
C939 gf180mcu_ocd_ip__classab_buffer_0.se_folded_cascode_np_ab_0.outa1n.t40 dvss 1.52274f
C940 gf180mcu_ocd_ip__classab_buffer_0.se_folded_cascode_np_ab_0.outa1n.t41 dvss 0.16129f
C941 gf180mcu_ocd_ip__classab_buffer_0.se_folded_cascode_np_ab_0.outa1n.t42 dvss 0.61511f
C942 gf180mcu_ocd_ip__classab_buffer_0.se_folded_cascode_np_ab_0.outa1n.t43 dvss 5.72914f
C943 gf180mcu_ocd_ip__classab_buffer_0.se_folded_cascode_np_ab_0.outa1n.n95 dvss 1.21335f
C944 gf180mcu_ocd_ip__classab_buffer_0.se_folded_cascode_np_ab_0.outa1n.t44 dvss 0.16129f
C945 gf180mcu_ocd_ip__classab_buffer_0.se_folded_cascode_np_ab_0.outa1n.t45 dvss 0.16129f
C946 gf180mcu_ocd_ip__classab_buffer_0.se_folded_cascode_np_ab_0.outa1n.t46 dvss 1.06892f
C947 gf180mcu_ocd_ip__classab_buffer_0.se_folded_cascode_np_ab_0.outa1n.t47 dvss 0.16129f
C948 gf180mcu_ocd_ip__classab_buffer_0.se_folded_cascode_np_ab_0.outa1p.n0 dvss 1.8045f
C949 gf180mcu_ocd_ip__classab_buffer_0.se_folded_cascode_np_ab_0.outa1p.n1 dvss 2.38217f
C950 gf180mcu_ocd_ip__classab_buffer_0.se_folded_cascode_np_ab_0.outa1p.n2 dvss 1.23233f
C951 gf180mcu_ocd_ip__classab_buffer_0.se_folded_cascode_np_ab_0.outa1p.n3 dvss 1.22801f
C952 gf180mcu_ocd_ip__classab_buffer_0.se_folded_cascode_np_ab_0.outa1p.n4 dvss 1.59963f
C953 gf180mcu_ocd_ip__classab_buffer_0.se_folded_cascode_np_ab_0.outa1p.n5 dvss 0.44169f
C954 gf180mcu_ocd_ip__classab_buffer_0.se_folded_cascode_np_ab_0.outa1p.n6 dvss 0.79946f
C955 gf180mcu_ocd_ip__classab_buffer_0.se_folded_cascode_np_ab_0.outa1p.n7 dvss 2.9172f
C956 gf180mcu_ocd_ip__classab_buffer_0.se_folded_cascode_np_ab_0.outa1p.n8 dvss 1.21348f
C957 gf180mcu_ocd_ip__classab_buffer_0.se_folded_cascode_np_ab_0.outa1p.n9 dvss 2.23813f
C958 gf180mcu_ocd_ip__classab_buffer_0.se_folded_cascode_np_ab_0.outa1p.n10 dvss 1.80129f
C959 gf180mcu_ocd_ip__classab_buffer_0.se_folded_cascode_np_ab_0.outa1p.n11 dvss 0.72886f
C960 gf180mcu_ocd_ip__classab_buffer_0.se_folded_cascode_np_ab_0.outa1p.n12 dvss 0.73034f
C961 gf180mcu_ocd_ip__classab_buffer_0.se_folded_cascode_np_ab_0.outa1p.n13 dvss 0.74962f
C962 gf180mcu_ocd_ip__classab_buffer_0.se_folded_cascode_np_ab_0.outa1p.n14 dvss 0.31926f
C963 gf180mcu_ocd_ip__classab_buffer_0.se_folded_cascode_np_ab_0.outa1p.n15 dvss 0.54093f
C964 gf180mcu_ocd_ip__classab_buffer_0.se_folded_cascode_np_ab_0.outa1p.n16 dvss 0.54093f
C965 gf180mcu_ocd_ip__classab_buffer_0.se_folded_cascode_np_ab_0.outa1p.n17 dvss 0.56833f
C966 gf180mcu_ocd_ip__classab_buffer_0.se_folded_cascode_np_ab_0.outa1p.n18 dvss 0.53877f
C967 gf180mcu_ocd_ip__classab_buffer_0.se_folded_cascode_np_ab_0.outa1p.n19 dvss 0.31926f
C968 gf180mcu_ocd_ip__classab_buffer_0.se_folded_cascode_np_ab_0.outa1p.n20 dvss 0.53877f
C969 gf180mcu_ocd_ip__classab_buffer_0.se_folded_cascode_np_ab_0.outa1p.n21 dvss 0.44427f
C970 gf180mcu_ocd_ip__classab_buffer_0.se_folded_cascode_np_ab_0.outa1p.n22 dvss 0.53877f
C971 gf180mcu_ocd_ip__classab_buffer_0.se_folded_cascode_np_ab_0.outa1p.n23 dvss 0.62401f
C972 gf180mcu_ocd_ip__classab_buffer_0.se_folded_cascode_np_ab_0.outa1p.n24 dvss 0.74531f
C973 gf180mcu_ocd_ip__classab_buffer_0.se_folded_cascode_np_ab_0.outa1p.n25 dvss 0.53661f
C974 gf180mcu_ocd_ip__classab_buffer_0.se_folded_cascode_np_ab_0.outa1p.n26 dvss 0.48732f
C975 gf180mcu_ocd_ip__classab_buffer_0.se_folded_cascode_np_ab_0.outa1p.n27 dvss 0.53661f
C976 gf180mcu_ocd_ip__classab_buffer_0.se_folded_cascode_np_ab_0.outa1p.n28 dvss 0.48802f
C977 gf180mcu_ocd_ip__classab_buffer_0.se_folded_cascode_np_ab_0.outa1p.n29 dvss 0.53446f
C978 gf180mcu_ocd_ip__classab_buffer_0.se_folded_cascode_np_ab_0.outa1p.n30 dvss 0.53446f
C979 gf180mcu_ocd_ip__classab_buffer_0.se_folded_cascode_np_ab_0.outa1p.n31 dvss 0.31926f
C980 gf180mcu_ocd_ip__classab_buffer_0.se_folded_cascode_np_ab_0.outa1p.n32 dvss 0.53446f
C981 gf180mcu_ocd_ip__classab_buffer_0.se_folded_cascode_np_ab_0.outa1p.n33 dvss 0.59328f
C982 gf180mcu_ocd_ip__classab_buffer_0.se_folded_cascode_np_ab_0.outa1p.n34 dvss 0.98744f
C983 gf180mcu_ocd_ip__classab_buffer_0.se_folded_cascode_np_ab_0.outa1p.n35 dvss 0.48875f
C984 gf180mcu_ocd_ip__classab_buffer_0.se_folded_cascode_np_ab_0.outa1p.n36 dvss 0.44121f
C985 gf180mcu_ocd_ip__classab_buffer_0.se_folded_cascode_np_ab_0.outa1p.n37 dvss 0.44201f
C986 gf180mcu_ocd_ip__classab_buffer_0.se_folded_cascode_np_ab_0.outa1p.n38 dvss 0.48759f
C987 gf180mcu_ocd_ip__classab_buffer_0.se_folded_cascode_np_ab_0.outa1p.n39 dvss 0.57889f
C988 gf180mcu_ocd_ip__classab_buffer_0.se_folded_cascode_np_ab_0.outa1p.n40 dvss 0.44194f
C989 gf180mcu_ocd_ip__classab_buffer_0.se_folded_cascode_np_ab_0.outa1p.n41 dvss 0.44129f
C990 gf180mcu_ocd_ip__classab_buffer_0.se_folded_cascode_np_ab_0.outa1p.n42 dvss 1.34354f
C991 gf180mcu_ocd_ip__classab_buffer_0.se_folded_cascode_np_ab_0.outa1p.n43 dvss 2.71685f
C992 gf180mcu_ocd_ip__classab_buffer_0.se_folded_cascode_np_ab_0.outa1p.n44 dvss 1.69583f
C993 gf180mcu_ocd_ip__classab_buffer_0.se_folded_cascode_np_ab_0.outa1p.n45 dvss 2.49258f
C994 gf180mcu_ocd_ip__classab_buffer_0.se_folded_cascode_np_ab_0.outa1p.n46 dvss 0.60438f
C995 gf180mcu_ocd_ip__classab_buffer_0.se_folded_cascode_np_ab_0.outa1p.t2 dvss 0.08708f
C996 gf180mcu_ocd_ip__classab_buffer_0.se_folded_cascode_np_ab_0.outa1p.t21 dvss 0.26015f
C997 gf180mcu_ocd_ip__classab_buffer_0.se_folded_cascode_np_ab_0.outa1p.t7 dvss 0.08708f
C998 gf180mcu_ocd_ip__classab_buffer_0.se_folded_cascode_np_ab_0.outa1p.t16 dvss 0.08708f
C999 gf180mcu_ocd_ip__classab_buffer_0.se_folded_cascode_np_ab_0.outa1p.t12 dvss 1.12608f
C1000 gf180mcu_ocd_ip__classab_buffer_0.se_folded_cascode_np_ab_0.outa1p.t17 dvss 0.08708f
C1001 gf180mcu_ocd_ip__classab_buffer_0.se_folded_cascode_np_ab_0.outa1p.t22 dvss 0.26015f
C1002 gf180mcu_ocd_ip__classab_buffer_0.se_folded_cascode_np_ab_0.outa1p.t0 dvss 0.26015f
C1003 gf180mcu_ocd_ip__classab_buffer_0.se_folded_cascode_np_ab_0.outa1p.t33 dvss 0.26015f
C1004 gf180mcu_ocd_ip__classab_buffer_0.se_folded_cascode_np_ab_0.outa1p.t19 dvss 0.26015f
C1005 gf180mcu_ocd_ip__classab_buffer_0.se_folded_cascode_np_ab_0.outa1p.t31 dvss 0.26015f
C1006 gf180mcu_ocd_ip__classab_buffer_0.se_folded_cascode_np_ab_0.outa1p.t5 dvss 0.08708f
C1007 gf180mcu_ocd_ip__classab_buffer_0.se_folded_cascode_np_ab_0.outa1p.n47 dvss 0.85392f
C1008 gf180mcu_ocd_ip__classab_buffer_0.se_folded_cascode_np_ab_0.outa1p.t18 dvss 0.26015f
C1009 gf180mcu_ocd_ip__classab_buffer_0.se_folded_cascode_np_ab_0.outa1p.t34 dvss 0.26015f
C1010 gf180mcu_ocd_ip__classab_buffer_0.se_folded_cascode_np_ab_0.outa1p.t1 dvss 0.26015f
C1011 gf180mcu_ocd_ip__classab_buffer_0.se_folded_cascode_np_ab_0.outa1p.t35 dvss 0.26015f
C1012 gf180mcu_ocd_ip__classab_buffer_0.se_folded_cascode_np_ab_0.outa1p.t8 dvss 0.08708f
C1013 gf180mcu_ocd_ip__classab_buffer_0.se_folded_cascode_np_ab_0.outa1p.n48 dvss 0.31926f
C1014 gf180mcu_ocd_ip__classab_buffer_0.se_folded_cascode_np_ab_0.outa1p.t3 dvss 0.08708f
C1015 gf180mcu_ocd_ip__classab_buffer_0.se_folded_cascode_np_ab_0.outa1p.n49 dvss 0.31926f
C1016 gf180mcu_ocd_ip__classab_buffer_0.se_folded_cascode_np_ab_0.outa1p.t20 dvss 0.26015f
C1017 gf180mcu_ocd_ip__classab_buffer_0.se_folded_cascode_np_ab_0.outa1p.t32 dvss 0.26015f
C1018 gf180mcu_ocd_ip__classab_buffer_0.se_folded_cascode_np_ab_0.outa1p.t4 dvss 0.08708f
C1019 gf180mcu_ocd_ip__classab_buffer_0.se_folded_cascode_np_ab_0.outa1p.t9 dvss 0.08708f
C1020 gf180mcu_ocd_ip__classab_buffer_0.se_folded_cascode_np_ab_0.outa1p.t13 dvss 0.08708f
C1021 gf180mcu_ocd_ip__classab_buffer_0.se_folded_cascode_np_ab_0.outa1p.n50 dvss 0.85818f
C1022 gf180mcu_ocd_ip__classab_buffer_0.se_folded_cascode_np_ab_0.outa1p.n51 dvss 0.31926f
C1023 gf180mcu_ocd_ip__classab_buffer_0.se_folded_cascode_np_ab_0.outa1p.t11 dvss 0.08708f
C1024 gf180mcu_ocd_ip__classab_buffer_0.se_folded_cascode_np_ab_0.outa1p.n52 dvss 0.31926f
C1025 gf180mcu_ocd_ip__classab_buffer_0.se_folded_cascode_np_ab_0.outa1p.t15 dvss 0.08708f
C1026 gf180mcu_ocd_ip__classab_buffer_0.se_folded_cascode_np_ab_0.outa1p.t14 dvss 0.08708f
C1027 gf180mcu_ocd_ip__classab_buffer_0.se_folded_cascode_np_ab_0.outa1p.t10 dvss 0.08708f
C1028 gf180mcu_ocd_ip__classab_buffer_0.se_folded_cascode_np_ab_0.outa1p.n53 dvss 0.31926f
C1029 gf180mcu_ocd_ip__classab_buffer_0.se_folded_cascode_np_ab_0.outa1p.t6 dvss 0.08708f
C1030 gf180mcu_ocd_ip__classab_buffer_0.se_folded_cascode_np_ab_0.outa1p.n54 dvss 0.56833f
C1031 gf180mcu_ocd_ip__classab_buffer_0.se_folded_cascode_np_ab_0.outa1p.t23 dvss 0.1862f
C1032 gf180mcu_ocd_ip__classab_buffer_0.se_folded_cascode_np_ab_0.outa1p.t24 dvss 0.1862f
C1033 gf180mcu_ocd_ip__classab_buffer_0.se_folded_cascode_np_ab_0.outa1p.t25 dvss 0.1862f
C1034 gf180mcu_ocd_ip__classab_buffer_0.se_folded_cascode_np_ab_0.outa1p.t26 dvss 0.1862f
C1035 gf180mcu_ocd_ip__classab_buffer_0.se_folded_cascode_np_ab_0.outa1p.t27 dvss 0.1862f
C1036 gf180mcu_ocd_ip__classab_buffer_0.se_folded_cascode_np_ab_0.outa1p.t28 dvss 8.40475f
C1037 gf180mcu_ocd_ip__classab_buffer_0.se_folded_cascode_np_ab_0.outa1p.t29 dvss 0.1862f
C1038 gf180mcu_ocd_ip__classab_buffer_0.se_folded_cascode_np_ab_0.outa1p.t30 dvss 0.1862f
C1039 gf180mcu_ocd_ip__classab_buffer_0.se_folded_cascode_np_ab_0.pfet_03v3_XWLNX2_0.D.n0 dvss 0.49147f
C1040 gf180mcu_ocd_ip__classab_buffer_0.se_folded_cascode_np_ab_0.pfet_03v3_XWLNX2_0.D.n1 dvss 0.26912f
C1041 gf180mcu_ocd_ip__classab_buffer_0.se_folded_cascode_np_ab_0.pfet_03v3_XWLNX2_0.D.n2 dvss 0.46406f
C1042 gf180mcu_ocd_ip__classab_buffer_0.se_folded_cascode_np_ab_0.pfet_03v3_XWLNX2_0.D.n3 dvss 0.381f
C1043 gf180mcu_ocd_ip__classab_buffer_0.se_folded_cascode_np_ab_0.pfet_03v3_XWLNX2_0.D.n4 dvss 0.31388f
C1044 gf180mcu_ocd_ip__classab_buffer_0.se_folded_cascode_np_ab_0.pfet_03v3_XWLNX2_0.D.n5 dvss 0.381f
C1045 gf180mcu_ocd_ip__classab_buffer_0.se_folded_cascode_np_ab_0.pfet_03v3_XWLNX2_0.D.n6 dvss 0.31388f
C1046 gf180mcu_ocd_ip__classab_buffer_0.se_folded_cascode_np_ab_0.pfet_03v3_XWLNX2_0.D.n7 dvss 0.381f
C1047 gf180mcu_ocd_ip__classab_buffer_0.se_folded_cascode_np_ab_0.pfet_03v3_XWLNX2_0.D.n8 dvss 0.381f
C1048 gf180mcu_ocd_ip__classab_buffer_0.se_folded_cascode_np_ab_0.pfet_03v3_XWLNX2_0.D.n9 dvss 0.381f
C1049 gf180mcu_ocd_ip__classab_buffer_0.se_folded_cascode_np_ab_0.pfet_03v3_XWLNX2_0.D.n10 dvss 0.381f
C1050 gf180mcu_ocd_ip__classab_buffer_0.se_folded_cascode_np_ab_0.pfet_03v3_XWLNX2_0.D.n11 dvss 0.381f
C1051 gf180mcu_ocd_ip__classab_buffer_0.se_folded_cascode_np_ab_0.pfet_03v3_XWLNX2_0.D.n12 dvss 0.40243f
C1052 gf180mcu_ocd_ip__classab_buffer_0.se_folded_cascode_np_ab_0.pfet_03v3_XWLNX2_0.D.n13 dvss 0.79427f
C1053 gf180mcu_ocd_ip__classab_buffer_0.se_folded_cascode_np_ab_0.pfet_03v3_XWLNX2_0.D.n14 dvss 0.72696f
C1054 gf180mcu_ocd_ip__classab_buffer_0.se_folded_cascode_np_ab_0.pfet_03v3_XWLNX2_0.D.n15 dvss 0.17793f
C1055 gf180mcu_ocd_ip__classab_buffer_0.se_folded_cascode_np_ab_0.pfet_03v3_XWLNX2_0.D.n16 dvss 0.28775f
C1056 gf180mcu_ocd_ip__classab_buffer_0.se_folded_cascode_np_ab_0.pfet_03v3_XWLNX2_0.D.n17 dvss 0.28775f
C1057 gf180mcu_ocd_ip__classab_buffer_0.se_folded_cascode_np_ab_0.pfet_03v3_XWLNX2_0.D.n18 dvss 0.17793f
C1058 gf180mcu_ocd_ip__classab_buffer_0.se_folded_cascode_np_ab_0.pfet_03v3_XWLNX2_0.D.n19 dvss 0.28775f
C1059 gf180mcu_ocd_ip__classab_buffer_0.se_folded_cascode_np_ab_0.pfet_03v3_XWLNX2_0.D.n20 dvss 0.30166f
C1060 gf180mcu_ocd_ip__classab_buffer_0.se_folded_cascode_np_ab_0.pfet_03v3_XWLNX2_0.D.n21 dvss 0.30166f
C1061 gf180mcu_ocd_ip__classab_buffer_0.se_folded_cascode_np_ab_0.pfet_03v3_XWLNX2_0.D.n22 dvss 0.30166f
C1062 gf180mcu_ocd_ip__classab_buffer_0.se_folded_cascode_np_ab_0.pfet_03v3_XWLNX2_0.D.n23 dvss 0.28867f
C1063 gf180mcu_ocd_ip__classab_buffer_0.se_folded_cascode_np_ab_0.pfet_03v3_XWLNX2_0.D.n24 dvss 0.26912f
C1064 gf180mcu_ocd_ip__classab_buffer_0.se_folded_cascode_np_ab_0.pfet_03v3_XWLNX2_0.D.n25 dvss 0.17793f
C1065 gf180mcu_ocd_ip__classab_buffer_0.se_folded_cascode_np_ab_0.pfet_03v3_XWLNX2_0.D.n26 dvss 0.28867f
C1066 gf180mcu_ocd_ip__classab_buffer_0.se_folded_cascode_np_ab_0.pfet_03v3_XWLNX2_0.D.n27 dvss 0.28867f
C1067 gf180mcu_ocd_ip__classab_buffer_0.se_folded_cascode_np_ab_0.pfet_03v3_XWLNX2_0.D.n28 dvss 0.26912f
C1068 gf180mcu_ocd_ip__classab_buffer_0.se_folded_cascode_np_ab_0.pfet_03v3_XWLNX2_0.D.n29 dvss 0.28774f
C1069 gf180mcu_ocd_ip__classab_buffer_0.se_folded_cascode_np_ab_0.pfet_03v3_XWLNX2_0.D.n30 dvss 0.28774f
C1070 gf180mcu_ocd_ip__classab_buffer_0.se_folded_cascode_np_ab_0.pfet_03v3_XWLNX2_0.D.n31 dvss 0.33466f
C1071 gf180mcu_ocd_ip__classab_buffer_0.se_folded_cascode_np_ab_0.pfet_03v3_XWLNX2_0.D.n32 dvss 0.28774f
C1072 gf180mcu_ocd_ip__classab_buffer_0.se_folded_cascode_np_ab_0.pfet_03v3_XWLNX2_0.D.n33 dvss 0.26912f
C1073 gf180mcu_ocd_ip__classab_buffer_0.se_folded_cascode_np_ab_0.pfet_03v3_XWLNX2_0.D.n34 dvss 0.17179f
C1074 gf180mcu_ocd_ip__classab_buffer_0.se_folded_cascode_np_ab_0.pfet_03v3_XWLNX2_0.D.n35 dvss 0.27674f
C1075 gf180mcu_ocd_ip__classab_buffer_0.se_folded_cascode_np_ab_0.pfet_03v3_XWLNX2_0.D.n36 dvss 0.26912f
C1076 gf180mcu_ocd_ip__classab_buffer_0.se_folded_cascode_np_ab_0.pfet_03v3_XWLNX2_0.D.n37 dvss 0.27674f
C1077 gf180mcu_ocd_ip__classab_buffer_0.se_folded_cascode_np_ab_0.pfet_03v3_XWLNX2_0.D.n38 dvss 0.17941f
C1078 gf180mcu_ocd_ip__classab_buffer_0.se_folded_cascode_np_ab_0.pfet_03v3_XWLNX2_0.D.n39 dvss 0.31864f
C1079 gf180mcu_ocd_ip__classab_buffer_0.se_folded_cascode_np_ab_0.pfet_03v3_XWLNX2_0.D.n40 dvss 1.49197f
C1080 gf180mcu_ocd_ip__classab_buffer_0.se_folded_cascode_np_ab_0.pfet_03v3_XWLNX2_0.D.n41 dvss 1.49694f
C1081 gf180mcu_ocd_ip__classab_buffer_0.se_folded_cascode_np_ab_0.pfet_03v3_XWLNX2_0.D.n42 dvss 0.27393f
C1082 gf180mcu_ocd_ip__classab_buffer_0.se_folded_cascode_np_ab_0.pfet_03v3_XWLNX2_0.D.n43 dvss 0.39611f
C1083 gf180mcu_ocd_ip__classab_buffer_0.se_folded_cascode_np_ab_0.pfet_03v3_XWLNX2_0.D.n44 dvss 0.39611f
C1084 gf180mcu_ocd_ip__classab_buffer_0.se_folded_cascode_np_ab_0.pfet_03v3_XWLNX2_0.D.n45 dvss 0.53484f
C1085 gf180mcu_ocd_ip__classab_buffer_0.se_folded_cascode_np_ab_0.pfet_03v3_XWLNX2_0.D.n46 dvss 0.39611f
C1086 gf180mcu_ocd_ip__classab_buffer_0.se_folded_cascode_np_ab_0.pfet_03v3_XWLNX2_0.D.n47 dvss 0.39565f
C1087 gf180mcu_ocd_ip__classab_buffer_0.se_folded_cascode_np_ab_0.pfet_03v3_XWLNX2_0.D.n48 dvss 0.39565f
C1088 gf180mcu_ocd_ip__classab_buffer_0.se_folded_cascode_np_ab_0.pfet_03v3_XWLNX2_0.D.n49 dvss 0.2744f
C1089 gf180mcu_ocd_ip__classab_buffer_0.se_folded_cascode_np_ab_0.pfet_03v3_XWLNX2_0.D.n50 dvss 0.39565f
C1090 gf180mcu_ocd_ip__classab_buffer_0.se_folded_cascode_np_ab_0.pfet_03v3_XWLNX2_0.D.n51 dvss 0.39549f
C1091 gf180mcu_ocd_ip__classab_buffer_0.se_folded_cascode_np_ab_0.pfet_03v3_XWLNX2_0.D.n52 dvss 0.39549f
C1092 gf180mcu_ocd_ip__classab_buffer_0.se_folded_cascode_np_ab_0.pfet_03v3_XWLNX2_0.D.n53 dvss 0.39549f
C1093 gf180mcu_ocd_ip__classab_buffer_0.se_folded_cascode_np_ab_0.pfet_03v3_XWLNX2_0.D.n54 dvss 0.42739f
C1094 gf180mcu_ocd_ip__classab_buffer_0.se_folded_cascode_np_ab_0.pfet_03v3_XWLNX2_0.D.n55 dvss 0.30682f
C1095 gf180mcu_ocd_ip__classab_buffer_0.se_folded_cascode_np_ab_0.pfet_03v3_XWLNX2_0.D.n56 dvss 0.42739f
C1096 gf180mcu_ocd_ip__classab_buffer_0.se_folded_cascode_np_ab_0.pfet_03v3_XWLNX2_0.D.n57 dvss 0.42739f
C1097 gf180mcu_ocd_ip__classab_buffer_0.se_folded_cascode_np_ab_0.pfet_03v3_XWLNX2_0.D.n58 dvss 3.27148f
C1098 gf180mcu_ocd_ip__classab_buffer_0.se_folded_cascode_np_ab_0.pfet_03v3_XWLNX2_0.D.t16 dvss 21.30473f
C1099 gf180mcu_ocd_ip__classab_buffer_0.se_folded_cascode_np_ab_0.pfet_03v3_XWLNX2_0.D.t19 dvss 23.4986f
C1100 gf180mcu_ocd_ip__classab_buffer_0.se_folded_cascode_np_ab_0.pfet_03v3_XWLNX2_0.D.n59 dvss 0.49827f
C1101 gf180mcu_ocd_ip__classab_buffer_0.se_folded_cascode_np_ab_0.pfet_03v3_XWLNX2_0.D.t25 dvss 17.72497f
C1102 gf180mcu_ocd_ip__classab_buffer_0.se_folded_cascode_np_ab_0.pfet_03v3_XWLNX2_0.D.t29 dvss 0.10302f
C1103 gf180mcu_ocd_ip__classab_buffer_0.se_folded_cascode_np_ab_0.pfet_03v3_XWLNX2_0.D.t28 dvss 0.10302f
C1104 gf180mcu_ocd_ip__classab_buffer_0.se_folded_cascode_np_ab_0.pfet_03v3_XWLNX2_0.D.t37 dvss 0.10302f
C1105 gf180mcu_ocd_ip__classab_buffer_0.se_folded_cascode_np_ab_0.pfet_03v3_XWLNX2_0.D.n60 dvss 0.59698f
C1106 gf180mcu_ocd_ip__classab_buffer_0.se_folded_cascode_np_ab_0.pfet_03v3_XWLNX2_0.D.n61 dvss 0.31388f
C1107 gf180mcu_ocd_ip__classab_buffer_0.se_folded_cascode_np_ab_0.pfet_03v3_XWLNX2_0.D.n62 dvss 0.58386f
C1108 gf180mcu_ocd_ip__classab_buffer_0.se_folded_cascode_np_ab_0.pfet_03v3_XWLNX2_0.D.t33 dvss 0.10302f
C1109 gf180mcu_ocd_ip__classab_buffer_0.se_folded_cascode_np_ab_0.pfet_03v3_XWLNX2_0.D.t32 dvss 0.10302f
C1110 gf180mcu_ocd_ip__classab_buffer_0.se_folded_cascode_np_ab_0.pfet_03v3_XWLNX2_0.D.t36 dvss 0.10302f
C1111 gf180mcu_ocd_ip__classab_buffer_0.se_folded_cascode_np_ab_0.pfet_03v3_XWLNX2_0.D.t35 dvss 0.10302f
C1112 gf180mcu_ocd_ip__classab_buffer_0.se_folded_cascode_np_ab_0.pfet_03v3_XWLNX2_0.D.t31 dvss 0.10302f
C1113 gf180mcu_ocd_ip__classab_buffer_0.se_folded_cascode_np_ab_0.pfet_03v3_XWLNX2_0.D.t34 dvss 0.10302f
C1114 gf180mcu_ocd_ip__classab_buffer_0.se_folded_cascode_np_ab_0.pfet_03v3_XWLNX2_0.D.t30 dvss 0.10302f
C1115 gf180mcu_ocd_ip__classab_buffer_0.se_folded_cascode_np_ab_0.pfet_03v3_XWLNX2_0.D.t23 dvss 0.10302f
C1116 gf180mcu_ocd_ip__classab_buffer_0.se_folded_cascode_np_ab_0.pfet_03v3_XWLNX2_0.D.t24 dvss 0.10302f
C1117 gf180mcu_ocd_ip__classab_buffer_0.se_folded_cascode_np_ab_0.pfet_03v3_XWLNX2_0.D.t6 dvss 0.04818f
C1118 gf180mcu_ocd_ip__classab_buffer_0.se_folded_cascode_np_ab_0.pfet_03v3_XWLNX2_0.D.t15 dvss 0.04818f
C1119 gf180mcu_ocd_ip__classab_buffer_0.se_folded_cascode_np_ab_0.pfet_03v3_XWLNX2_0.D.t11 dvss 0.04818f
C1120 gf180mcu_ocd_ip__classab_buffer_0.se_folded_cascode_np_ab_0.pfet_03v3_XWLNX2_0.D.n63 dvss 0.18978f
C1121 gf180mcu_ocd_ip__classab_buffer_0.se_folded_cascode_np_ab_0.pfet_03v3_XWLNX2_0.D.n64 dvss 0.27455f
C1122 gf180mcu_ocd_ip__classab_buffer_0.se_folded_cascode_np_ab_0.pfet_03v3_XWLNX2_0.D.t2 dvss 0.04818f
C1123 gf180mcu_ocd_ip__classab_buffer_0.se_folded_cascode_np_ab_0.pfet_03v3_XWLNX2_0.D.t9 dvss 0.04818f
C1124 gf180mcu_ocd_ip__classab_buffer_0.se_folded_cascode_np_ab_0.pfet_03v3_XWLNX2_0.D.t12 dvss 0.04818f
C1125 gf180mcu_ocd_ip__classab_buffer_0.se_folded_cascode_np_ab_0.pfet_03v3_XWLNX2_0.D.n65 dvss 0.18978f
C1126 gf180mcu_ocd_ip__classab_buffer_0.se_folded_cascode_np_ab_0.pfet_03v3_XWLNX2_0.D.t3 dvss 0.04818f
C1127 gf180mcu_ocd_ip__classab_buffer_0.se_folded_cascode_np_ab_0.pfet_03v3_XWLNX2_0.D.n66 dvss 0.36465f
C1128 gf180mcu_ocd_ip__classab_buffer_0.se_folded_cascode_np_ab_0.pfet_03v3_XWLNX2_0.D.n67 dvss 0.38372f
C1129 gf180mcu_ocd_ip__classab_buffer_0.se_folded_cascode_np_ab_0.pfet_03v3_XWLNX2_0.D.t10 dvss 0.04818f
C1130 gf180mcu_ocd_ip__classab_buffer_0.se_folded_cascode_np_ab_0.pfet_03v3_XWLNX2_0.D.n68 dvss 0.17793f
C1131 gf180mcu_ocd_ip__classab_buffer_0.se_folded_cascode_np_ab_0.pfet_03v3_XWLNX2_0.D.t1 dvss 1.08718f
C1132 gf180mcu_ocd_ip__classab_buffer_0.se_folded_cascode_np_ab_0.pfet_03v3_XWLNX2_0.D.n69 dvss 0.17793f
C1133 gf180mcu_ocd_ip__classab_buffer_0.se_folded_cascode_np_ab_0.pfet_03v3_XWLNX2_0.D.n70 dvss 0.17941f
C1134 gf180mcu_ocd_ip__classab_buffer_0.se_folded_cascode_np_ab_0.pfet_03v3_XWLNX2_0.D.t5 dvss 0.04818f
C1135 gf180mcu_ocd_ip__classab_buffer_0.se_folded_cascode_np_ab_0.pfet_03v3_XWLNX2_0.D.n71 dvss 0.17793f
C1136 gf180mcu_ocd_ip__classab_buffer_0.se_folded_cascode_np_ab_0.pfet_03v3_XWLNX2_0.D.n72 dvss 0.17179f
C1137 gf180mcu_ocd_ip__classab_buffer_0.se_folded_cascode_np_ab_0.pfet_03v3_XWLNX2_0.D.t0 dvss 0.04818f
C1138 gf180mcu_ocd_ip__classab_buffer_0.se_folded_cascode_np_ab_0.pfet_03v3_XWLNX2_0.D.n73 dvss 0.17793f
C1139 gf180mcu_ocd_ip__classab_buffer_0.se_folded_cascode_np_ab_0.pfet_03v3_XWLNX2_0.D.t7 dvss 0.04818f
C1140 gf180mcu_ocd_ip__classab_buffer_0.se_folded_cascode_np_ab_0.pfet_03v3_XWLNX2_0.D.n74 dvss 0.25419f
C1141 gf180mcu_ocd_ip__classab_buffer_0.se_folded_cascode_np_ab_0.pfet_03v3_XWLNX2_0.D.t14 dvss 0.04818f
C1142 gf180mcu_ocd_ip__classab_buffer_0.se_folded_cascode_np_ab_0.pfet_03v3_XWLNX2_0.D.t8 dvss 0.04818f
C1143 gf180mcu_ocd_ip__classab_buffer_0.se_folded_cascode_np_ab_0.pfet_03v3_XWLNX2_0.D.n75 dvss 0.17793f
C1144 gf180mcu_ocd_ip__classab_buffer_0.se_folded_cascode_np_ab_0.pfet_03v3_XWLNX2_0.D.n76 dvss 0.17941f
C1145 gf180mcu_ocd_ip__classab_buffer_0.se_folded_cascode_np_ab_0.pfet_03v3_XWLNX2_0.D.n77 dvss 0.27455f
C1146 gf180mcu_ocd_ip__classab_buffer_0.se_folded_cascode_np_ab_0.pfet_03v3_XWLNX2_0.D.n78 dvss 0.17941f
C1147 gf180mcu_ocd_ip__classab_buffer_0.se_folded_cascode_np_ab_0.pfet_03v3_XWLNX2_0.D.t4 dvss 0.04818f
C1148 gf180mcu_ocd_ip__classab_buffer_0.se_folded_cascode_np_ab_0.pfet_03v3_XWLNX2_0.D.t13 dvss 0.04818f
C1149 gf180mcu_ocd_ip__classab_buffer_0.se_folded_cascode_np_ab_0.pfet_03v3_XWLNX2_0.D.n79 dvss 0.25331f
C1150 gf180mcu_ocd_ip__classab_buffer_0.se_folded_cascode_np_ab_0.pfet_03v3_XWLNX2_0.D.n80 dvss 0.17941f
C1151 gf180mcu_ocd_ip__classab_buffer_0.se_folded_cascode_np_ab_0.pfet_03v3_XWLNX2_0.D.t22 dvss 0.10302f
C1152 gf180mcu_ocd_ip__classab_buffer_0.se_folded_cascode_np_ab_0.pfet_03v3_XWLNX2_0.D.n81 dvss 0.40888f
C1153 gf180mcu_ocd_ip__classab_buffer_0.se_folded_cascode_np_ab_0.pfet_03v3_XWLNX2_0.D.t27 dvss 0.10302f
C1154 gf180mcu_ocd_ip__classab_buffer_0.se_folded_cascode_np_ab_0.pfet_03v3_XWLNX2_0.D.t26 dvss 0.10302f
C1155 gf180mcu_ocd_ip__classab_buffer_0.se_folded_cascode_np_ab_0.pfet_03v3_XWLNX2_0.D.n82 dvss 0.33371f
C1156 gf180mcu_ocd_ip__classab_buffer_0.se_folded_cascode_np_ab_0.pfet_03v3_XWLNX2_0.D.n83 dvss 0.40861f
C1157 gf180mcu_ocd_ip__classab_buffer_0.se_folded_cascode_np_ab_0.pfet_03v3_XWLNX2_0.D.n84 dvss 0.31388f
C1158 gf180mcu_ocd_ip__classab_buffer_0.se_folded_cascode_np_ab_0.pfet_03v3_XWLNX2_0.D.n85 dvss 0.31388f
C1159 gf180mcu_ocd_ip__classab_buffer_0.se_folded_cascode_np_ab_0.pfet_03v3_XWLNX2_0.D.n86 dvss 0.2744f
C1160 gf180mcu_ocd_ip__classab_buffer_0.se_folded_cascode_np_ab_0.pfet_03v3_XWLNX2_0.D.n87 dvss 0.31388f
C1161 gf180mcu_ocd_ip__classab_buffer_0.se_folded_cascode_np_ab_0.pfet_03v3_XWLNX2_0.D.n88 dvss 0.30682f
C1162 gf180mcu_ocd_ip__classab_buffer_0.se_folded_cascode_np_ab_0.pfet_03v3_XWLNX2_0.D.n89 dvss 0.31388f
C1163 gf180mcu_ocd_ip__classab_buffer_0.se_folded_cascode_np_ab_0.pfet_03v3_XWLNX2_0.D.n90 dvss 0.2744f
C1164 gf180mcu_ocd_ip__classab_buffer_0.se_folded_cascode_np_ab_0.pfet_03v3_XWLNX2_0.D.n91 dvss 0.27393f
C1165 gf180mcu_ocd_ip__classab_buffer_0.se_folded_cascode_np_ab_0.pfet_03v3_XWLNX2_0.D.n92 dvss 0.27455f
C1166 gf180mcu_ocd_ip__classab_buffer_0.se_folded_cascode_np_ab_0.pfet_03v3_XWLNX2_0.D.n93 dvss 0.41621f
C1167 gf180mcu_ocd_ip__classab_buffer_0.se_folded_cascode_np_ab_0.pfet_03v3_XWLNX2_0.D.n94 dvss 0.17941f
C1168 gf180mcu_ocd_ip__classab_buffer_0.se_folded_cascode_np_ab_0.pfet_03v3_XWLNX2_0.D.n95 dvss 0.38451f
C1169 gf180mcu_ocd_ip__classab_buffer_0.se_folded_cascode_np_ab_0.pfet_03v3_XWLNX2_0.D.t21 dvss -0.01056f
C1170 gf180mcu_ocd_ip__classab_buffer_0.se_folded_cascode_np_ab_0.pfet_03v3_XWLNX2_0.D.n97 dvss 0.0674f
C1171 dvss.t288 dvss 0.38456f
C1172 dvss.t63 dvss 60.53083f
C1173 dvss.t279 dvss 0.14066f
C1174 dvss.t118 dvss 5.8501f
C1175 dvss.t117 dvss 5.8501f
C1176 dvss.t276 dvss 0.15742f
C1177 dvss.t291 dvss 0.33328f
C1178 dvss.t14 dvss 0.58884f
C1179 dvss.t10 dvss 0.33354f
C1180 dvss.t6 dvss 0.33585f
C1181 dvss.t2 dvss 0.49225f
C1182 dvss.t242 dvss 0.4104f
C1183 dvss.t257 dvss 0.66515f
C1184 dvss.t60 dvss 0.34444f
C1185 dvss.t273 dvss 0.37152f
C1186 dvss.t204 dvss 16.11435f
C1187 dvdd.t42 dvss 3.89421f
C1188 dvdd.n0 dvss 1.49423f
C1189 dvdd.n1 dvss 0.85636f
C1190 dvdd.t70 dvss 0.30121f
C1191 dvdd.n2 dvss 0.47884f
C1192 dvdd.n3 dvss 0.1319f
C1193 dvdd.n4 dvss 5.73223f
C1194 dvdd.n5 dvss 2.34734f
C1195 dvdd.n6 dvss 8.93521f
C1196 dvdd.t14 dvss 44.3387f
C1197 dvdd.t168 dvss 2.19204f
C1198 dvdd.n7 dvss 1.02691f
C1199 dvdd.n8 dvss 0.28408f
C1200 dvdd.n9 dvss 0.35202f
C1201 dvdd.n10 dvss 0.22941f
C1202 dvdd.n12 dvss 0.07383f
C1203 dvdd.n13 dvss 0.06763f
C1204 dvdd.t295 dvss 1.13172f
C1205 dvdd.t283 dvss 1.03079f
C1206 dvdd.t105 dvss 1.02561f
C1207 dvdd.t244 dvss 1.02537f
C1208 dvdd.t243 dvss 1.03087f
C1209 dvdd.n14 dvss 0.20339f
C1210 dvdd.n15 dvss 0.427f
C1211 dvdd.t281 dvss 1.15026f
C1212 dvdd.n16 dvss 0.0282f
C1213 dvdd.n17 dvss 0.022f
C1214 dvdd.n18 dvss 0.76308f
C1215 dvdd.n19 dvss 0.66963f
C1216 dvdd.n20 dvss 0.42722f
C1217 dvdd.n21 dvss 0.93096f
C1218 dvdd.n22 dvss 0.49453f
C1219 dvdd.n23 dvss 0.62833f
C1220 dvdd.n24 dvss 0.76166f
C1221 dvdd.n25 dvss 0.17799f
C1222 dvdd.n26 dvss 0.06353f
C1223 dvdd.n27 dvss 0.10541f
C1224 dvdd.n29 dvss 1.62904f
C1225 dvdd.n30 dvss 0.21701f
C1226 dvdd.n31 dvss 1.17986f
C1227 dvdd.n32 dvss 2.72686f
C1228 dvdd.t210 dvss 2.12854f
C1229 dvdd.n33 dvss 0.2715f
C1230 dvdd.n34 dvss 0.23919f
C1231 dvdd.n35 dvss 0.12654f
C1232 dvdd.n36 dvss 0.49003f
C1233 dvdd.n37 dvss 0.47408f
C1234 dvdd.n38 dvss 0.91461f
C1235 dvdd.n39 dvss 0.54697f
C1236 dvdd.n40 dvss 0.05446f
C1237 dvdd.t107 dvss 0.75471f
C1238 dvdd.n41 dvss 2.47077f
C1239 dvdd.n42 dvss 1.39008f
C1240 dvdd.n43 dvss 0.1666f
C1241 dvdd.n44 dvss 0.06769f
C1242 dvdd.n45 dvss 0.13758f
C1243 dvdd.n46 dvss 0.13548f
C1244 dvdd.n47 dvss 0.14647f
C1245 dvdd.n48 dvss 0.06358f
C1246 dvdd.n49 dvss 0.13949f
C1247 dvdd.n50 dvss 6.11937f
C1248 dvdd.n51 dvss 1.33001f
C1249 dvdd.n52 dvss 6.18386f
C1250 dvdd.n53 dvss 0.80626f
C1251 dvdd.n54 dvss 0.37447f
C1252 dvdd.n55 dvss 0.2956f
C1253 dvdd.n56 dvss 0.14668f
C1254 dvdd.n57 dvss 0.20163f
C1255 dvdd.n58 dvss 0.14737f
C1256 dvdd.t217 dvss 0.80273f
C1257 dvdd.n59 dvss 0.96555f
C1258 dvdd.n60 dvss 1.34254f
C1259 dvdd.t87 dvss 1.38302f
C1260 dvdd.t114 dvss 1.62845f
C1261 dvdd.t113 dvss 1.28857f
C1262 dvdd.t32 dvss 1.53335f
C1263 dvdd.n61 dvss 1.27382f
C1264 dvdd.n62 dvss 0.39437f
C1265 dvdd.t292 dvss 0.97588f
C1266 dvdd.n63 dvss 0.89396f
C1267 dvdd.t16 dvss 1.13098f
C1268 dvdd.t12 dvss 0.95791f
C1269 dvdd.t51 dvss 0.41824f
C1270 dvdd.t56 dvss 0.35679f
C1271 dvdd.t48 dvss 6.19141f
C1272 dvdd.t99 dvss 0.04496f
C1273 dvdd.t54 dvss 0.43362f
C1274 dvdd.t215 dvss 0.23602f
C1275 dvdd.t46 dvss 1.00704f
C1276 dvdd.t103 dvss 1.00704f
C1277 dvdd.t47 dvss 1.00704f
C1278 dvdd.t100 dvss 1.00704f
C1279 dvdd.t49 dvss 1.00704f
C1280 dvdd.t104 dvss 1.00704f
C1281 dvdd.t52 dvss 0.79349f
C1282 dvdd.n64 dvss 0.9923f
C1283 dvdd.t45 dvss 0.49902f
C1284 dvdd.t102 dvss 1.00704f
C1285 dvdd.t44 dvss 1.00704f
C1286 dvdd.t98 dvss 1.00704f
C1287 dvdd.t43 dvss 1.00704f
C1288 dvdd.t101 dvss 1.00704f
C1289 dvdd.t41 dvss 1.00704f
C1290 dvdd.t97 dvss 0.80698f
C1291 dvdd.n65 dvss 0.89994f
C1292 dvdd.n66 dvss 0.48554f
C1293 dvdd.n67 dvss 0.21324f
C1294 dvdd.n68 dvss 0.17184f
C1295 dvdd.t219 dvss 3.13286f
C1296 dvdd.n69 dvss 0.33936f
C1297 dvdd.n70 dvss 0.05752f
C1298 dvdd.n71 dvss 0.20459f
C1299 dvdd.n72 dvss 1.8681f
C1300 dvdd.t218 dvss 1.41435f
C1301 dvdd.t86 dvss 0.95894f
C1302 dvdd.n73 dvss 0.83987f
C1303 dvdd.n74 dvss 1.39574f
C1304 dvdd.t79 dvss 0.94188f
C1305 dvdd.t31 dvss 0.76166f
C1306 dvdd.t72 dvss 1.30571f
C1307 dvdd.t15 dvss 0.87047f
C1308 dvdd.t20 dvss 0.76166f
C1309 dvdd.t27 dvss 1.32101f
C1310 dvdd.t291 dvss 0.46074f
C1311 dvdd.t21 dvss 0.76166f
C1312 dvdd.t29 dvss 1.1561f
C1313 dvdd.t40 dvss 1.38731f
C1314 dvdd.t22 dvss 0.68176f
C1315 dvdd.n75 dvss 0.14099f
C1316 dvdd.t163 dvss 1.06026f
C1317 dvdd.t160 dvss 1.42465f
C1318 dvdd.t280 dvss 0.84157f
C1319 dvdd.t284 dvss 1.52333f
C1320 dvdd.t17 dvss 0.88407f
C1321 dvdd.t23 dvss 0.76166f
C1322 dvdd.t30 dvss 1.40092f
C1323 dvdd.t293 dvss 1.14249f
C1324 dvdd.t24 dvss 0.76166f
C1325 dvdd.t282 dvss 1.14249f
C1326 dvdd.t279 dvss 1.40092f
C1327 dvdd.t25 dvss 0.76166f
C1328 dvdd.t39 dvss 0.88407f
C1329 dvdd.t28 dvss 1.52333f
C1330 dvdd.t286 dvss 0.89767f
C1331 dvdd.t167 dvss 0.76166f
C1332 dvdd.t285 dvss 1.38731f
C1333 dvdd.t13 dvss 0.82287f
C1334 dvdd.n76 dvss 0.21734f
C1335 dvdd.n77 dvss 0.65185f
C1336 dvdd.n78 dvss 0.318f
C1337 dvdd.n79 dvss 0.21252f
C1338 dvdd.t55 dvss 0.58485f
C1339 dvdd.t159 dvss 0.76166f
C1340 dvdd.t57 dvss 0.58145f
C1341 dvdd.t162 dvss 0.76166f
C1342 dvdd.t50 dvss 0.58145f
C1343 dvdd.t164 dvss 0.76166f
C1344 dvdd.t59 dvss 1.01498f
C1345 dvdd.t141 dvss 0.76166f
C1346 dvdd.t58 dvss 0.58145f
C1347 dvdd.t142 dvss 0.68176f
C1348 dvdd.t143 dvss 0.66135f
C1349 dvdd.t60 dvss 0.84157f
C1350 dvdd.t61 dvss 1.52333f
C1351 dvdd.t26 dvss 1.11529f
C1352 dvdd.t18 dvss 0.76166f
C1353 dvdd.t71 dvss 1.1697f
C1354 dvdd.t11 dvss 1.37371f
C1355 dvdd.t19 dvss 0.76166f
C1356 dvdd.t290 dvss 0.69706f
C1357 dvdd.t89 dvss 2.7226f
C1358 dvdd.n80 dvss 0.72998f
C1359 dvdd.t270 dvss 0.12369f
C1360 dvdd.t213 dvss 0.78309f
C1361 dvdd.n81 dvss 1.49916f
C1362 dvdd.t223 dvss 1.05303f
C1363 dvdd.t76 dvss 0.62175f
C1364 dvdd.t7 dvss 0.58718f
C1365 dvdd.t4 dvss 0.39855f
C1366 dvdd.t272 dvss 0.1041f
C1367 dvdd.t220 dvss 0.08184f
C1368 dvdd.t221 dvss 0.12507f
C1369 dvdd.t264 dvss 0.14732f
C1370 dvdd.t266 dvss 0.1041f
C1371 dvdd.t212 dvss 0.08184f
C1372 dvdd.t214 dvss 0.12507f
C1373 dvdd.t273 dvss 0.14732f
C1374 dvdd.t275 dvss 0.1041f
C1375 dvdd.t225 dvss 0.08184f
C1376 dvdd.t226 dvss 0.12507f
C1377 dvdd.t267 dvss 0.14732f
C1378 dvdd.t269 dvss 0.1041f
C1379 dvdd.t222 dvss 0.08184f
C1380 dvdd.t224 dvss 0.12507f
C1381 dvdd.t276 dvss 0.14732f
C1382 dvdd.t278 dvss 0.1041f
C1383 dvdd.t229 dvss 0.08184f
C1384 dvdd.t230 dvss 0.12507f
C1385 dvdd.t73 dvss 0.14732f
C1386 dvdd.t75 dvss 0.1041f
C1387 dvdd.t227 dvss 0.08184f
C1388 dvdd.t228 dvss 0.12507f
C1389 dvdd.t121 dvss 0.14732f
C1390 dvdd.t123 dvss 0.1041f
C1391 dvdd.t9 dvss 0.08184f
C1392 dvdd.t10 dvss 0.12507f
C1393 dvdd.t138 dvss 0.14732f
C1394 dvdd.t140 dvss 0.1041f
C1395 dvdd.t6 dvss 0.08184f
C1396 dvdd.t8 dvss 0.12507f
C1397 dvdd.t127 dvss 0.14732f
C1398 dvdd.t129 dvss 0.1041f
C1399 dvdd.t3 dvss 0.08184f
C1400 dvdd.t5 dvss 0.12353f
C1401 dvdd.n82 dvss 0.15283f
C1402 dvdd.t1 dvss 0.68204f
C1403 dvdd.t117 dvss 0.796f
C1404 dvdd.t131 dvss 0.54086f
C1405 dvdd.t81 dvss 0.75765f
C1406 dvdd.t236 dvss 0.122f
C1407 dvdd.t238 dvss 0.1041f
C1408 dvdd.t0 dvss 0.08184f
C1409 dvdd.t2 dvss 0.12507f
C1410 dvdd.t287 dvss 0.14732f
C1411 dvdd.t289 dvss 0.1041f
C1412 dvdd.t119 dvss 0.08184f
C1413 dvdd.t120 dvss 0.12507f
C1414 dvdd.t246 dvss 0.14732f
C1415 dvdd.t248 dvss 0.1041f
C1416 dvdd.t116 dvss 0.08184f
C1417 dvdd.t118 dvss 0.12507f
C1418 dvdd.t239 dvss 0.14732f
C1419 dvdd.t241 dvss 0.1041f
C1420 dvdd.t234 dvss 0.08184f
C1421 dvdd.t235 dvss 0.12507f
C1422 dvdd.t144 dvss 0.14732f
C1423 dvdd.t146 dvss 0.1041f
C1424 dvdd.t133 dvss 0.08184f
C1425 dvdd.t134 dvss 0.12507f
C1426 dvdd.t260 dvss 0.14732f
C1427 dvdd.t262 dvss 0.1041f
C1428 dvdd.t130 dvss 0.08184f
C1429 dvdd.t132 dvss 0.12507f
C1430 dvdd.t124 dvss 0.14732f
C1431 dvdd.t126 dvss 0.1041f
C1432 dvdd.t80 dvss 0.08184f
C1433 dvdd.t82 dvss 0.12507f
C1434 dvdd.t231 dvss 0.14732f
C1435 dvdd.t233 dvss 0.1041f
C1436 dvdd.t135 dvss 0.08184f
C1437 dvdd.t136 dvss 0.12495f
C1438 dvdd.t137 dvss 0.33443f
C1439 dvdd.n83 dvss 5.12286f
C1440 dvdd.n84 dvss 0.31049f
C1441 dvdd.n85 dvss 0.09252f
C1442 dvdd.n86 dvss 0.09252f
C1443 dvdd.n87 dvss 0.30215f
C1444 dvdd.n88 dvss 0.04569f
C1445 dvdd.t209 dvss 0.30365f
C1446 dvdd.n90 dvss 0.31049f
C1447 dvdd.t298 dvss 0.35264f
C1448 dvdd.t147 dvss 0.31022f
C1449 dvdd.n91 dvss 0.20681f
C1450 dvdd.t106 dvss 0.31022f
C1451 dvdd.t259 dvss 0.35264f
C1452 dvdd.n92 dvss 3.99127f
C1453 dvdd.t69 dvss 2.39282f
C1454 dvdd.t252 dvss 2.37959f
C1455 dvdd.t250 dvss 1.52675f
C1456 dvdd.t77 dvss 3.0535f
C1457 dvdd.t251 dvss 3.0714f
C1458 dvdd.t38 dvss 1.12506f
C1459 dvdd.t242 dvss 0.99372f
C1460 dvdd.t245 dvss 0.99729f
C1461 dvdd.n93 dvss 0.10282f
C1462 dvdd.t294 dvss 1.08312f
C1463 dvdd.t88 dvss 1.84029f
C1464 dvdd.n94 dvss 0.43218f
C1465 dvdd.n95 dvss 0.34814f
C1466 dvdd.t296 dvss 1.06874f
C1467 dvdd.n96 dvss 0.067f
C1468 dvdd.t263 dvss 1.11556f
C1469 dvdd.n97 dvss 0.07392f
C1470 dvdd.n98 dvss 0.06707f
C1471 dvdd.n99 dvss 0.06769f
C1472 dvdd.n100 dvss 0.07397f
C1473 dvdd.n101 dvss 0.06771f
C1474 dvdd.n102 dvss 0.06693f
C1475 dvdd.n103 dvss 0.14668f
C1476 dvdd.n104 dvss 0.14668f
C1477 dvdd.n105 dvss 0.08463f
C1478 dvdd.t297 dvss 1.08231f
C1479 dvdd.n106 dvss 0.06358f
C1480 dvdd.n107 dvss 0.04642f
C1481 dvdd.n108 dvss 0.09872f
C1482 dvdd.n109 dvss 0.06347f
C1483 dvdd.n110 dvss 0.06363f
C1484 dvdd.n111 dvss 0.10308f
C1485 dvdd.t258 dvss 0.99904f
C1486 dvdd.n112 dvss 0.10286f
C1487 dvdd.n113 dvss 0.09798f
C1488 dvdd.t78 dvss 0.99453f
C1489 dvdd.n114 dvss 0.06218f
C1490 dvdd.t148 dvss 1.10048f
C1491 dvdd.n115 dvss 0.3787f
C1492 dvdd.n116 dvss 0.14668f
C1493 dvdd.n117 dvss 0.15395f
C1494 dvdd.t35 dvss 2.3644f
C1495 dvdd.t33 dvss 3.19093f
C1496 dvdd.n118 dvss 2.52111f
C1497 dvdd.t216 dvss 2.77458f
C1498 dvdd.t253 dvss 4.33574f
C1499 dvdd.t249 dvss 4.03158f
C1500 dvdd.t37 dvss 2.48097f
C1501 dvdd.n119 dvss 2.52357f
C1502 dvdd.n120 dvss 0.55322f
C1503 dvdd.n121 dvss 0.97049f
C1504 dvdd.t34 dvss 2.70653f
C1505 dvdd.t36 dvss 2.99608f
C1506 dvdd.n122 dvss 9.40889f
.ends
