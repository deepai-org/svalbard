** sch_path: /home/tim/gits/gf180mcu_ocd_chipalooza/dependencies/gf180mcu_ocd_ip__biasgen/xschem/gf180mcu_ocd_ip__biasgen.sch
.subckt gf180mcu_ocd_ip__biasgen ena avdd avss ref_in dvdd vbg ref_sel_vbg dvss bandgap_sink2[1] bandgap_sink2[0]
+ voltgen_source[4] voltgen_source[3] voltgen_source[2] voltgen_source[1] voltgen_source[0] bandgap_sink2_ibias voltgen_sink1[2] voltgen_sink1[1]
+ voltgen_sink1[0] voltgen_source_ibias idac1_source[4] idac1_source[3] idac1_source[2] idac1_source[1] idac1_source[0] voltgen_sink1_ibias
+ idac1_source_ibias idac2_source_ibias idac2_source[4] idac2_source[3] idac2_source[2] idac2_source[1] idac2_source[0] ref_sel_coarse ref_sel_fine
+ bandgap_sink1[2] bandgap_sink1[1] bandgap_sink1[0] bandgap_sink1_ibias voltgen_sink2[2] voltgen_sink2[1] voltgen_sink2[0] voltgen_sink2_ibias
*.PININFO avdd:B avss:B dvdd:B dvss:B ena:I ref_in:I vbg:I ref_sel_vbg:I bandgap_sink1[2:0]:I voltgen_sink1[2:0]:I
*+ voltgen_sink2[2:0]:I bandgap_sink1_ibias:B voltgen_sink1_ibias:B voltgen_sink2_ibias:B ref_sel_fine:I ref_sel_coarse:I voltgen_source_ibias:B
*+ voltgen_source[4:0]:I bandgap_sink2[1:0]:I bandgap_sink2_ibias:B idac1_source_ibias:B idac1_source[4:0]:I idac2_source_ibias:B idac2_source[4:0]:I
x1 avdd ena vbg net1 avss dvdd dvss ref_sel_vbg ref_in dvss nbias pcasc pbias net2 dvss ncasc ref_sel_fine ref_sel_coarse avdd
+ bias_generator_fe
* noconn #net1
* noconn #net2
x13 dvdd dvss avdd pcasc pbias voltgen_source[4] voltgen_source[3] voltgen_source[2] voltgen_source[1] voltgen_source[0]
+ voltgen_source_ibias avss avdd avdd bias_generator_be0p
x8[4] net4 avss ncasc nbias avss avss avss bias_nstack
x8[3] net4 avss ncasc nbias avss avss avss bias_nstack
x8[2] net4 avss ncasc nbias avss avss avss bias_nstack
x8[1] net4 avss ncasc nbias avss avss avss bias_nstack
x8[0] net4 avss ncasc nbias avss avss avss bias_nstack
x9[4] avdd pbias pcasc avdd net3 avdd avdd bias_pstack
x9[3] avdd pbias pcasc avdd net3 avdd avdd bias_pstack
x9[2] avdd pbias pcasc avdd net3 avdd avdd bias_pstack
x9[1] avdd pbias pcasc avdd net3 avdd avdd bias_pstack
x9[0] avdd pbias pcasc avdd net3 avdd avdd bias_pstack
* noconn #net4
* noconn #net3
x8 dvdd dvss avdd nbias avss bandgap_sink1[2] bandgap_sink1[1] bandgap_sink1[0] bandgap_sink1_ibias ncasc avss avss
+ bias_generator_ben1um
x3 dvdd dvss avdd nbias avss voltgen_sink1[2] voltgen_sink1[1] voltgen_sink1[0] voltgen_sink1_ibias ncasc avss avss
+ bias_generator_ben1um
x4 dvdd dvss avdd nbias avss voltgen_sink2[2] voltgen_sink2[1] voltgen_sink2[0] voltgen_sink2_ibias ncasc avss avss
+ bias_generator_ben1um
x2 dvdd dvss avdd nbias avss bandgap_sink2[1] bandgap_sink2[0] bandgap_sink2_ibias ncasc avss avss bias_generator_ben250nm
x5 dvdd dvss avdd pcasc pbias idac1_source[4] idac1_source[3] idac1_source[2] idac1_source[1] idac1_source[0] idac1_source_ibias
+ avss avdd avdd bias_generator_be0p
x6 dvdd dvss avdd pcasc pbias idac2_source[4] idac2_source[3] idac2_source[2] idac2_source[1] idac2_source[0] idac2_source_ibias
+ avss avdd avdd bias_generator_be0p
.ends

* expanding   symbol:  bias_generator_fe.sym # of pins=19
** sym_path: /home/tim/gits/gf180mcu_ocd_chipalooza/dependencies/gf180mcu_ocd_ip__biasgen/xschem/bias_generator_fe.sym
** sch_path: /home/tim/gits/gf180mcu_ocd_chipalooza/dependencies/gf180mcu_ocd_ip__biasgen/xschem/bias_generator_fe.sch
.subckt bias_generator_fe avdd ena vbg src_test0 avss dvdd ena_src_test0 ref_sel_vbg ref_in dvss nbias pcasc pbias snk_test0
+ ena_snk_test0 ncasc ref_sel_fine ref_sel_coarse shld2
*.PININFO ref_in:I avss:B ref_sel_vbg:I avdd:B ena_src_test0:I ena_snk_test0:I src_test0:B snk_test0:B vbg:I ena:I dvdd:B dvss:B
*+ pcasc:O pbias:O nbias:O ncasc:O ref_sel_fine:I shld2:B ref_sel_coarse:I
x4 net1 ena_5v0 ncasc nbias avss avss avss bias_nstack
x13[1] avdd pbias pcasc enb_test0_5v0 src_test0 shld2 avdd bias_pstack
x13[0] avdd pbias pcasc enb_test0_5v0 src_test0 shld2 avdd bias_pstack
x17[1] snk_test0 ena_test0_5v0 ncasc nbias avss avss avss bias_nstack
x17[0] snk_test0 ena_test0_5v0 ncasc nbias avss avss avss bias_nstack
x1 ref_sel_vbg net2 enb_vbg_5v0 avdd avss level_shift_5v
x11 net5 ena_snk_test0 ena_test0_5v0 avdd avss level_shift_5v
x23 ena_src_test0 net4 enb_test0_5v0 avdd avss level_shift_5v
x24 dvdd dvdd dvss dvss net3 ena gf180mcu_as_sc_mcu7t3v3__inv_2
x35 dvdd dvdd dvss dvss net2 ref_sel_vbg gf180mcu_as_sc_mcu7t3v3__inv_2
x36 net3 ena ena_5v0 avdd avss level_shift_5v
Vmeas vfb net10 0
.save i(vmeas)
x19[2] avdd pbias pcasc enb_std_5v0 vfb shld2 avdd bias_pstack
x19[1] avdd pbias pcasc enb_std_5v0 vfb shld2 avdd bias_pstack
x19[0] avdd pbias pcasc enb_std_5v0 vfb shld2 avdd bias_pstack
x5[6] dvdd dvdd dvss dvss gf180mcu_as_sc_mcu7t3v3__fillcap_4
x5[5] dvdd dvdd dvss dvss gf180mcu_as_sc_mcu7t3v3__fillcap_4
x5[4] dvdd dvdd dvss dvss gf180mcu_as_sc_mcu7t3v3__fillcap_4
x5[3] dvdd dvdd dvss dvss gf180mcu_as_sc_mcu7t3v3__fillcap_4
x5[2] dvdd dvdd dvss dvss gf180mcu_as_sc_mcu7t3v3__fillcap_4
x5[1] dvdd dvdd dvss dvss gf180mcu_as_sc_mcu7t3v3__fillcap_4
x5[0] dvdd dvdd dvss dvss gf180mcu_as_sc_mcu7t3v3__fillcap_4
x5 dvdd dvdd dvss dvss ref_sel_vbg gf180mcu_as_sc_mcu7t3v3__diode_2
x6 dvdd dvdd dvss dvss ena gf180mcu_as_sc_mcu7t3v3__diode_2
x7 dvdd dvdd dvss dvss ena_src_test0 gf180mcu_as_sc_mcu7t3v3__diode_2
x8 dvdd dvdd dvss dvss ena_snk_test0 gf180mcu_as_sc_mcu7t3v3__diode_2
x9 dvdd dvdd dvss dvss net4 ena_src_test0 gf180mcu_as_sc_mcu7t3v3__inv_2
x10 dvdd dvdd dvss dvss net5 ena_snk_test0 gf180mcu_as_sc_mcu7t3v3__inv_2
x12 net2 ref_sel_vbg ena_vbg_5v0 avdd avss level_shift_5v
x1[15] nset ena_5v0 ncasc nbias avss avss avss bias_nset
x1[14] nset ena_5v0 ncasc nbias avss avss avss bias_nset
x1[13] nset ena_5v0 ncasc nbias avss avss avss bias_nset
x1[12] nset ena_5v0 ncasc nbias avss avss avss bias_nset
x1[11] nset ena_5v0 ncasc nbias avss avss avss bias_nset
x1[10] nset ena_5v0 ncasc nbias avss avss avss bias_nset
x1[9] nset ena_5v0 ncasc nbias avss avss avss bias_nset
x1[8] nset ena_5v0 ncasc nbias avss avss avss bias_nset
x1[7] nset ena_5v0 ncasc nbias avss avss avss bias_nset
x1[6] nset ena_5v0 ncasc nbias avss avss avss bias_nset
x1[5] nset ena_5v0 ncasc nbias avss avss avss bias_nset
x1[4] nset ena_5v0 ncasc nbias avss avss avss bias_nset
x1[3] nset ena_5v0 ncasc nbias avss avss avss bias_nset
x1[2] nset ena_5v0 ncasc nbias avss avss avss bias_nset
x1[1] nset ena_5v0 ncasc nbias avss avss avss bias_nset
x1[0] nset ena_5v0 ncasc nbias avss avss avss bias_nset
x14 avdd pbias pcasc ena_vbg_5v0 net6 avdd bias_pset
Vmeas1 net7 nset 0
.save i(vmeas1)
Vmeas2 net6 net1 0
.save i(vmeas2)
x3 avdd pbias vbg vfb nbias avss ena_vbg_5v0 bias_amp_large
x2[15] avdd pbias pcasc enb_fine_5v0 vfb shld2 avdd bias_pstack
x2[14] avdd pbias pcasc enb_fine_5v0 vfb shld2 avdd bias_pstack
x2[13] avdd pbias pcasc enb_fine_5v0 vfb shld2 avdd bias_pstack
x2[12] avdd pbias pcasc enb_fine_5v0 vfb shld2 avdd bias_pstack
x2[11] avdd pbias pcasc enb_fine_5v0 vfb shld2 avdd bias_pstack
x2[10] avdd pbias pcasc enb_fine_5v0 vfb shld2 avdd bias_pstack
x2[9] avdd pbias pcasc enb_fine_5v0 vfb shld2 avdd bias_pstack
x2[8] avdd pbias pcasc enb_fine_5v0 vfb shld2 avdd bias_pstack
x2[7] avdd pbias pcasc enb_fine_5v0 vfb shld2 avdd bias_pstack
x2[6] avdd pbias pcasc enb_fine_5v0 vfb shld2 avdd bias_pstack
x2[5] avdd pbias pcasc enb_fine_5v0 vfb shld2 avdd bias_pstack
x2[4] avdd pbias pcasc enb_fine_5v0 vfb shld2 avdd bias_pstack
x2[3] avdd pbias pcasc enb_fine_5v0 vfb shld2 avdd bias_pstack
x2[2] avdd pbias pcasc enb_fine_5v0 vfb shld2 avdd bias_pstack
x2[1] avdd pbias pcasc enb_fine_5v0 vfb shld2 avdd bias_pstack
x2[0] avdd pbias pcasc enb_fine_5v0 vfb shld2 avdd bias_pstack
x15 net9 net8 enb_fine_5v0 avdd avss level_shift_5v
x16 dvdd dvdd dvss dvss net9 net8 gf180mcu_as_sc_mcu7t3v3__inv_2
x13 avdd pbias pcasc enb_coarse_5v0 vfb shld2 avdd bias_pstack
x19 net12 net11 enb_coarse_5v0 avdd avss level_shift_5v
x20 dvdd dvdd dvss dvss net12 net11 gf180mcu_as_sc_mcu7t3v3__inv_2
x21 net14 net13 enb_std_5v0 avdd avss level_shift_5v
x22 dvdd dvdd dvss dvss net14 net13 gf180mcu_as_sc_mcu7t3v3__inv_2
x30 avdd dummypbias pcasc enb_vbg_5v0 net6 pbias avdd bias_pset2
x2 dvdd dvdd dvss dvss ref_sel_coarse gf180mcu_as_sc_mcu7t3v3__diode_2
x31 dvdd dvdd dvss dvss ref_sel_fine gf180mcu_as_sc_mcu7t3v3__diode_2
x4[1] avdd dummypbias pcasc avdd vfb pbias avdd bias_pstack
x4[0] avdd dummypbias pcasc avdd vfb pbias avdd bias_pstack
x3[1] nset avss ncasc nbias avss avss avss bias_nstack
x3[0] nset avss ncasc nbias avss avss avss bias_nstack
XC2 pbias vfb cap_mim_2f0_m4m5_noshield c_width=11e-6 c_length=11e-6 m=1
XR2 avss net10 avss ppolyf_u_1k r_width=1e-6 r_length=1210e-6 m=1
x17 dvdd dvdd dvss dvss net15 ref_sel_fine ref_sel_coarse gf180mcu_as_sc_mcu7t3v3__nand2_2
x18 dvdd dvdd dvss dvss net17 ref_sel_coarse net18 gf180mcu_as_sc_mcu7t3v3__nand2_2
x25 dvdd dvdd dvss dvss net11 ref_sel_vbg net15 gf180mcu_as_sc_mcu7t3v3__nand2_2
x26 dvdd dvdd dvss dvss net8 ref_sel_vbg net16 gf180mcu_as_sc_mcu7t3v3__nand2_2
x27 dvdd dvdd dvss dvss net13 ref_sel_vbg net17 gf180mcu_as_sc_mcu7t3v3__nand2_2
x28 dvdd dvdd dvss dvss net18 ref_sel_fine gf180mcu_as_sc_mcu7t3v3__inv_2
x29 dvdd dvdd dvss dvss net16 net18 ref_sel_coarse gf180mcu_as_sc_mcu7t3v3__nor2_2
XR1 net7 ref_in avss ppolyf_u_1k r_width=1e-6 r_length=848e-6 m=1
x32[6] dvss dvdd gf180mcu_as_sc_mcu7t3v3__tap_2
x32[5] dvss dvdd gf180mcu_as_sc_mcu7t3v3__tap_2
x32[4] dvss dvdd gf180mcu_as_sc_mcu7t3v3__tap_2
x32[3] dvss dvdd gf180mcu_as_sc_mcu7t3v3__tap_2
x32[2] dvss dvdd gf180mcu_as_sc_mcu7t3v3__tap_2
x32[1] dvss dvdd gf180mcu_as_sc_mcu7t3v3__tap_2
x32[0] dvss dvdd gf180mcu_as_sc_mcu7t3v3__tap_2
.ends

* expanding   symbol:  bias_generator_be0p.sym # of pins=10
** sym_path: /home/tim/gits/gf180mcu_ocd_chipalooza/dependencies/gf180mcu_ocd_ip__biasgen/xschem/bias_generator_be0p.sym
** sch_path: /home/tim/gits/gf180mcu_ocd_chipalooza/dependencies/gf180mcu_ocd_ip__biasgen/xschem/bias_generator_be0p.sch
.subckt bias_generator_be0p dvdd dvss avdd pcasc pbias source_ena[4] source_ena[3] source_ena[2] source_ena[1] source_ena[0]
+ source_ibias avss shld2 shld3
*.PININFO avss:B avdd:B dvdd:B dvss:B pcasc:I pbias:I source_ena[4:0]:I source_ibias:B shld2:B shld3:B
x9[4] source_ena[4] net1[4] source_ena_b_5v0[4] avdd avss level_shift_5v
x9[3] source_ena[3] net1[3] source_ena_b_5v0[3] avdd avss level_shift_5v
x9[2] source_ena[2] net1[2] source_ena_b_5v0[2] avdd avss level_shift_5v
x9[1] source_ena[1] net1[1] source_ena_b_5v0[1] avdd avss level_shift_5v
x9[0] source_ena[0] net1[0] source_ena_b_5v0[0] avdd avss level_shift_5v
x46[4] dvdd dvdd dvss dvss net1[4] source_ena[4] gf180mcu_as_sc_mcu7t3v3__inv_2
x46[3] dvdd dvdd dvss dvss net1[3] source_ena[3] gf180mcu_as_sc_mcu7t3v3__inv_2
x46[2] dvdd dvdd dvss dvss net1[2] source_ena[2] gf180mcu_as_sc_mcu7t3v3__inv_2
x46[1] dvdd dvdd dvss dvss net1[1] source_ena[1] gf180mcu_as_sc_mcu7t3v3__inv_2
x46[0] dvdd dvdd dvss dvss net1[0] source_ena[0] gf180mcu_as_sc_mcu7t3v3__inv_2
x23[4] dvdd dvdd dvss dvss gf180mcu_as_sc_mcu7t3v3__fillcap_4
x23[3] dvdd dvdd dvss dvss gf180mcu_as_sc_mcu7t3v3__fillcap_4
x23[2] dvdd dvdd dvss dvss gf180mcu_as_sc_mcu7t3v3__fillcap_4
x23[1] dvdd dvdd dvss dvss gf180mcu_as_sc_mcu7t3v3__fillcap_4
x23[0] dvdd dvdd dvss dvss gf180mcu_as_sc_mcu7t3v3__fillcap_4
x78[4] dvdd dvdd dvss dvss source_ena[4] gf180mcu_as_sc_mcu7t3v3__diode_2
x78[3] dvdd dvdd dvss dvss source_ena[3] gf180mcu_as_sc_mcu7t3v3__diode_2
x78[2] dvdd dvdd dvss dvss source_ena[2] gf180mcu_as_sc_mcu7t3v3__diode_2
x78[1] dvdd dvdd dvss dvss source_ena[1] gf180mcu_as_sc_mcu7t3v3__diode_2
x78[0] dvdd dvdd dvss dvss source_ena[0] gf180mcu_as_sc_mcu7t3v3__diode_2
x9 avdd pbias pcasc source_ena_b_5v0[0] source_ibias shld2 shld3 bias_pstack
x10[1] avdd pbias pcasc source_ena_b_5v0[1] source_ibias shld2 shld3 bias_pstack
x10[0] avdd pbias pcasc source_ena_b_5v0[1] source_ibias shld2 shld3 bias_pstack
x1[3] avdd pbias pcasc source_ena_b_5v0[2] source_ibias shld2 shld3 bias_pstack
x1[2] avdd pbias pcasc source_ena_b_5v0[2] source_ibias shld2 shld3 bias_pstack
x1[1] avdd pbias pcasc source_ena_b_5v0[2] source_ibias shld2 shld3 bias_pstack
x1[0] avdd pbias pcasc source_ena_b_5v0[2] source_ibias shld2 shld3 bias_pstack
x2[7] avdd pbias pcasc source_ena_b_5v0[3] source_ibias shld2 shld3 bias_pstack
x2[6] avdd pbias pcasc source_ena_b_5v0[3] source_ibias shld2 shld3 bias_pstack
x2[5] avdd pbias pcasc source_ena_b_5v0[3] source_ibias shld2 shld3 bias_pstack
x2[4] avdd pbias pcasc source_ena_b_5v0[3] source_ibias shld2 shld3 bias_pstack
x2[3] avdd pbias pcasc source_ena_b_5v0[3] source_ibias shld2 shld3 bias_pstack
x2[2] avdd pbias pcasc source_ena_b_5v0[3] source_ibias shld2 shld3 bias_pstack
x2[1] avdd pbias pcasc source_ena_b_5v0[3] source_ibias shld2 shld3 bias_pstack
x2[0] avdd pbias pcasc source_ena_b_5v0[3] source_ibias shld2 shld3 bias_pstack
x3[15] avdd pbias pcasc source_ena_b_5v0[4] source_ibias shld2 shld3 bias_pstack
x3[14] avdd pbias pcasc source_ena_b_5v0[4] source_ibias shld2 shld3 bias_pstack
x3[13] avdd pbias pcasc source_ena_b_5v0[4] source_ibias shld2 shld3 bias_pstack
x3[12] avdd pbias pcasc source_ena_b_5v0[4] source_ibias shld2 shld3 bias_pstack
x3[11] avdd pbias pcasc source_ena_b_5v0[4] source_ibias shld2 shld3 bias_pstack
x3[10] avdd pbias pcasc source_ena_b_5v0[4] source_ibias shld2 shld3 bias_pstack
x3[9] avdd pbias pcasc source_ena_b_5v0[4] source_ibias shld2 shld3 bias_pstack
x3[8] avdd pbias pcasc source_ena_b_5v0[4] source_ibias shld2 shld3 bias_pstack
x3[7] avdd pbias pcasc source_ena_b_5v0[4] source_ibias shld2 shld3 bias_pstack
x3[6] avdd pbias pcasc source_ena_b_5v0[4] source_ibias shld2 shld3 bias_pstack
x3[5] avdd pbias pcasc source_ena_b_5v0[4] source_ibias shld2 shld3 bias_pstack
x3[4] avdd pbias pcasc source_ena_b_5v0[4] source_ibias shld2 shld3 bias_pstack
x3[3] avdd pbias pcasc source_ena_b_5v0[4] source_ibias shld2 shld3 bias_pstack
x3[2] avdd pbias pcasc source_ena_b_5v0[4] source_ibias shld2 shld3 bias_pstack
x3[1] avdd pbias pcasc source_ena_b_5v0[4] source_ibias shld2 shld3 bias_pstack
x3[0] avdd pbias pcasc source_ena_b_5v0[4] source_ibias shld2 shld3 bias_pstack
x4[4] dvss dvdd gf180mcu_as_sc_mcu7t3v3__tap_2
x4[3] dvss dvdd gf180mcu_as_sc_mcu7t3v3__tap_2
x4[2] dvss dvdd gf180mcu_as_sc_mcu7t3v3__tap_2
x4[1] dvss dvdd gf180mcu_as_sc_mcu7t3v3__tap_2
x4[0] dvss dvdd gf180mcu_as_sc_mcu7t3v3__tap_2
.ends

* expanding   symbol:  bias_nstack.sym # of pins=7
** sym_path: /home/tim/gits/gf180mcu_ocd_chipalooza/dependencies/gf180mcu_ocd_ip__biasgen/xschem/bias_nstack.sym
** sch_path: /home/tim/gits/gf180mcu_ocd_chipalooza/dependencies/gf180mcu_ocd_ip__biasgen/xschem/bias_nstack.sch
.subckt bias_nstack itail ena ncasc nbias avss shld2 shld3
*.PININFO avss:B ena:I nbias:I itail:B ncasc:I shld2:B shld3:B
XM1 itail ena net2 avss nfet_05v0 L=1.0u W=3.0u nf=1 ad='int((nf+1)/2) * W/nf * 0.18u' as='int((nf+2)/2) * W/nf * 0.18u' pd='2*int((nf+1)/2) * (W/nf + 0.18u)'
+ ps='2*int((nf+2)/2) * (W/nf + 0.18u)' nrd='0.18u / W' nrs='0.18u / W' sa=0 sb=0 sd=0 m=1 par=1
XM2 net2 ncasc net1 avss nfet_05v0 L=1.0u W=3.0u nf=1 ad='int((nf+1)/2) * W/nf * 0.18u' as='int((nf+2)/2) * W/nf * 0.18u' pd='2*int((nf+1)/2) * (W/nf + 0.18u)'
+ ps='2*int((nf+2)/2) * (W/nf + 0.18u)' nrd='0.18u / W' nrs='0.18u / W' sa=0 sb=0 sd=0 m=1 par=1
XM3 net1 nbias avss avss nfet_05v0 L=1.0u W=3.0u nf=1 ad='int((nf+1)/2) * W/nf * 0.18u' as='int((nf+2)/2) * W/nf * 0.18u' pd='2*int((nf+1)/2) * (W/nf + 0.18u)'
+ ps='2*int((nf+2)/2) * (W/nf + 0.18u)' nrd='0.18u / W' nrs='0.18u / W' sa=0 sb=0 sd=0 m=1 par=1
.ends

* expanding   symbol:  bias_pstack.sym # of pins=7
** sym_path: /home/tim/gits/gf180mcu_ocd_chipalooza/dependencies/gf180mcu_ocd_ip__biasgen/xschem/bias_pstack.sym
** sch_path: /home/tim/gits/gf180mcu_ocd_chipalooza/dependencies/gf180mcu_ocd_ip__biasgen/xschem/bias_pstack.sch
.subckt bias_pstack avdd pbias pcasc enb itail shld2 shld3
*.PININFO avdd:B itail:B enb:I pcasc:I pbias:I shld2:B shld3:B
XM1 net1 pbias avdd avdd pfet_05v0 L=1.0u W=3.0u nf=1 ad='int((nf+1)/2) * W/nf * 0.18u' as='int((nf+2)/2) * W/nf * 0.18u' pd='2*int((nf+1)/2) * (W/nf + 0.18u)'
+ ps='2*int((nf+2)/2) * (W/nf + 0.18u)' nrd='0.18u / W' nrs='0.18u / W' sa=0 sb=0 sd=0 m=1 par=1
XM2 net2 pcasc net1 avdd pfet_05v0 L=1.0u W=3.0u nf=1 ad='int((nf+1)/2) * W/nf * 0.18u' as='int((nf+2)/2) * W/nf * 0.18u' pd='2*int((nf+1)/2) * (W/nf + 0.18u)'
+ ps='2*int((nf+2)/2) * (W/nf + 0.18u)' nrd='0.18u / W' nrs='0.18u / W' sa=0 sb=0 sd=0 m=1 par=1
XM3 itail enb net2 avdd pfet_05v0 L=1.0u W=3.0u nf=1 ad='int((nf+1)/2) * W/nf * 0.18u' as='int((nf+2)/2) * W/nf * 0.18u' pd='2*int((nf+1)/2) * (W/nf + 0.18u)'
+ ps='2*int((nf+2)/2) * (W/nf + 0.18u)' nrd='0.18u / W' nrs='0.18u / W' sa=0 sb=0 sd=0 m=1 par=1
.ends

* expanding   symbol:  bias_generator_ben1um.sym # of pins=10
** sym_path: /home/tim/gits/gf180mcu_ocd_chipalooza/dependencies/gf180mcu_ocd_ip__biasgen/xschem/bias_generator_ben1um.sym
** sch_path: /home/tim/gits/gf180mcu_ocd_chipalooza/dependencies/gf180mcu_ocd_ip__biasgen/xschem/bias_generator_ben1um.sch
.subckt bias_generator_ben1um dvdd dvss avdd nbias avss sink_ena[2] sink_ena[1] sink_ena[0] sink_ibias ncasc shld2 shld3
*.PININFO avss:B avdd:B dvdd:B dvss:B nbias:I ncasc:I sink_ibias:B sink_ena[2:0]:I shld2:B shld3:B
x7[2] dvdd dvdd dvss dvss gf180mcu_as_sc_mcu7t3v3__fillcap_4
x7[1] dvdd dvdd dvss dvss gf180mcu_as_sc_mcu7t3v3__fillcap_4
x7[0] dvdd dvdd dvss dvss gf180mcu_as_sc_mcu7t3v3__fillcap_4
x6[2] dvdd dvdd dvss dvss sink_ena[2] gf180mcu_as_sc_mcu7t3v3__diode_2
x6[1] dvdd dvdd dvss dvss sink_ena[1] gf180mcu_as_sc_mcu7t3v3__diode_2
x6[0] dvdd dvdd dvss dvss sink_ena[0] gf180mcu_as_sc_mcu7t3v3__diode_2
x1[2] sink_ibias sink_ena_5v0[0] ncasc nbias avss shld2 shld3 bias_nstack
x1[1] sink_ibias sink_ena_5v0[0] ncasc nbias avss shld2 shld3 bias_nstack
x1[0] sink_ibias sink_ena_5v0[0] ncasc nbias avss shld2 shld3 bias_nstack
x2 sink_ibias sink_ena_5v0[1] ncasc nbias avss shld2 shld3 bias_nstack
x3 sink_ibias sink_ena_5v0[2] ncasc nbias avss shld2 shld3 bias_nstack
x4[2] net1[2] sink_ena[2] sink_ena_5v0[2] avdd avss level_shift_5v
x4[1] net1[1] sink_ena[1] sink_ena_5v0[1] avdd avss level_shift_5v
x4[0] net1[0] sink_ena[0] sink_ena_5v0[0] avdd avss level_shift_5v
x5[2] dvdd dvdd dvss dvss net1[2] sink_ena[2] gf180mcu_as_sc_mcu7t3v3__inv_2
x5[1] dvdd dvdd dvss dvss net1[1] sink_ena[1] gf180mcu_as_sc_mcu7t3v3__inv_2
x5[0] dvdd dvdd dvss dvss net1[0] sink_ena[0] gf180mcu_as_sc_mcu7t3v3__inv_2
x2[9] dummy_ibias avss ncasc nbias avss shld2 shld3 bias_nstack
x2[8] dummy_ibias avss ncasc nbias avss shld2 shld3 bias_nstack
x2[7] dummy_ibias avss ncasc nbias avss shld2 shld3 bias_nstack
x2[6] dummy_ibias avss ncasc nbias avss shld2 shld3 bias_nstack
x2[5] dummy_ibias avss ncasc nbias avss shld2 shld3 bias_nstack
x2[4] dummy_ibias avss ncasc nbias avss shld2 shld3 bias_nstack
x2[3] dummy_ibias avss ncasc nbias avss shld2 shld3 bias_nstack
x2[2] dummy_ibias avss ncasc nbias avss shld2 shld3 bias_nstack
x2[1] dummy_ibias avss ncasc nbias avss shld2 shld3 bias_nstack
x2[0] dummy_ibias avss ncasc nbias avss shld2 shld3 bias_nstack
x3[2] dvss dvdd gf180mcu_as_sc_mcu7t3v3__tap_2
x3[1] dvss dvdd gf180mcu_as_sc_mcu7t3v3__tap_2
x3[0] dvss dvdd gf180mcu_as_sc_mcu7t3v3__tap_2
.ends

* expanding   symbol:  bias_generator_ben250nm.sym # of pins=10
** sym_path: /home/tim/gits/gf180mcu_ocd_chipalooza/dependencies/gf180mcu_ocd_ip__biasgen/xschem/bias_generator_ben250nm.sym
** sch_path: /home/tim/gits/gf180mcu_ocd_chipalooza/dependencies/gf180mcu_ocd_ip__biasgen/xschem/bias_generator_ben250nm.sch
.subckt bias_generator_ben250nm dvdd dvss avdd nbias avss sink_ena[1] sink_ena[0] sink_ibias ncasc shld2 shld3
*.PININFO avss:B avdd:B dvdd:B dvss:B nbias:I ncasc:I sink_ibias:B sink_ena[1:0]:I shld2:B shld3:B
x7[1] dvdd dvdd dvss dvss gf180mcu_as_sc_mcu7t3v3__fillcap_4
x7[0] dvdd dvdd dvss dvss gf180mcu_as_sc_mcu7t3v3__fillcap_4
x6[1] dvdd dvdd dvss dvss sink_ena[1] gf180mcu_as_sc_mcu7t3v3__diode_2
x6[0] dvdd dvdd dvss dvss sink_ena[0] gf180mcu_as_sc_mcu7t3v3__diode_2
x2 sink_ibias sink_ena_5v0[1] ncasc nbias avss shld2 shld3 bias_nstack
x3 sink_ibias sink_ena_5v0[0] ncasc nbias avss shld2 shld3 bias_nstack
x4[1] net1[1] sink_ena[1] sink_ena_5v0[1] avdd avss level_shift_5v
x4[0] net1[0] sink_ena[0] sink_ena_5v0[0] avdd avss level_shift_5v
x5[1] dvdd dvdd dvss dvss net1[1] sink_ena[1] gf180mcu_as_sc_mcu7t3v3__inv_2
x5[0] dvdd dvdd dvss dvss net1[0] sink_ena[0] gf180mcu_as_sc_mcu7t3v3__inv_2
x1[7] dummy_bias avss ncasc nbias avss shld2 shld3 bias_nstack
x1[6] dummy_bias avss ncasc nbias avss shld2 shld3 bias_nstack
x1[5] dummy_bias avss ncasc nbias avss shld2 shld3 bias_nstack
x1[4] dummy_bias avss ncasc nbias avss shld2 shld3 bias_nstack
x1[3] dummy_bias avss ncasc nbias avss shld2 shld3 bias_nstack
x1[2] dummy_bias avss ncasc nbias avss shld2 shld3 bias_nstack
x1[1] dummy_bias avss ncasc nbias avss shld2 shld3 bias_nstack
x1[0] dummy_bias avss ncasc nbias avss shld2 shld3 bias_nstack
x2[1] dvss dvdd gf180mcu_as_sc_mcu7t3v3__tap_2
x2[0] dvss dvdd gf180mcu_as_sc_mcu7t3v3__tap_2
.ends

* expanding   symbol:  level_shift_5v.sym # of pins=3
** sym_path: /home/tim/gits/gf180mcu_ocd_chipalooza/dependencies/gf180mcu_ocd_ip__biasgen/xschem/level_shift_5v.sym
** sch_path: /home/tim/gits/gf180mcu_ocd_chipalooza/dependencies/gf180mcu_ocd_ip__biasgen/xschem/level_shift_5v.sch
.subckt level_shift_5v in_n in_p out vdd vss
*.PININFO in_n:I in_p:I out:O
XM8 net1 in_p vss vss nfet_05v0 L=0.6u W=4.0u nf=1 ad='int((nf+1)/2) * W/nf * 0.18u' as='int((nf+2)/2) * W/nf * 0.18u' pd='2*int((nf+1)/2) * (W/nf + 0.18u)'
+ ps='2*int((nf+2)/2) * (W/nf + 0.18u)' nrd='0.18u / W' nrs='0.18u / W' sa=0 sb=0 sd=0 m=2 par=2
XM10 net1 S1_N vdd vdd pfet_05v0 L=0.5u W=1.0u nf=1 ad='int((nf+1)/2) * W/nf * 0.18u' as='int((nf+2)/2) * W/nf * 0.18u' pd='2*int((nf+1)/2) * (W/nf + 0.18u)'
+ ps='2*int((nf+2)/2) * (W/nf + 0.18u)' nrd='0.18u / W' nrs='0.18u / W' sa=0 sb=0 sd=0 m=2 par=2
XM2 out S2_N vdd vdd pfet_05v0 L=0.5u W=2.0u nf=1 ad='int((nf+1)/2) * W/nf * 0.18u' as='int((nf+2)/2) * W/nf * 0.18u' pd='2*int((nf+1)/2) * (W/nf + 0.18u)'
+ ps='2*int((nf+2)/2) * (W/nf + 0.18u)' nrd='0.18u / W' nrs='0.18u / W' sa=0 sb=0 sd=0 m=4 par=4
XM9 S1_N net1 vdd vdd pfet_05v0 L=0.5u W=1.0u nf=1 ad='int((nf+1)/2) * W/nf * 0.18u' as='int((nf+2)/2) * W/nf * 0.18u' pd='2*int((nf+1)/2) * (W/nf + 0.18u)'
+ ps='2*int((nf+2)/2) * (W/nf + 0.18u)' nrd='0.18u / W' nrs='0.18u / W' sa=0 sb=0 sd=0 m=2 par=2
XM4 S2_N S1_N vdd vdd pfet_05v0 L=0.5u W=2.0u nf=1 ad='int((nf+1)/2) * W/nf * 0.18u' as='int((nf+2)/2) * W/nf * 0.18u' pd='2*int((nf+1)/2) * (W/nf + 0.18u)'
+ ps='2*int((nf+2)/2) * (W/nf + 0.18u)' nrd='0.18u / W' nrs='0.18u / W' sa=0 sb=0 sd=0 m=2 par=2
XM1 S1_N in_n vss vss nfet_05v0 L=0.6u W=4.0u nf=1 ad='int((nf+1)/2) * W/nf * 0.18u' as='int((nf+2)/2) * W/nf * 0.18u' pd='2*int((nf+1)/2) * (W/nf + 0.18u)'
+ ps='2*int((nf+2)/2) * (W/nf + 0.18u)' nrd='0.18u / W' nrs='0.18u / W' sa=0 sb=0 sd=0 m=2 par=2
XM3 S2_N S1_N vss vss nfet_05v0 L=0.6u W=1.0u nf=1 ad='int((nf+1)/2) * W/nf * 0.18u' as='int((nf+2)/2) * W/nf * 0.18u' pd='2*int((nf+1)/2) * (W/nf + 0.18u)'
+ ps='2*int((nf+2)/2) * (W/nf + 0.18u)' nrd='0.18u / W' nrs='0.18u / W' sa=0 sb=0 sd=0 m=2 par=2
XM5 out S2_N vss vss nfet_05v0 L=0.6u W=1.0u nf=1 ad='int((nf+1)/2) * W/nf * 0.18u' as='int((nf+2)/2) * W/nf * 0.18u' pd='2*int((nf+1)/2) * (W/nf + 0.18u)'
+ ps='2*int((nf+2)/2) * (W/nf + 0.18u)' nrd='0.18u / W' nrs='0.18u / W' sa=0 sb=0 sd=0 m=4 par=4
.ends

* expanding   symbol:  bias_nset.sym # of pins=7
** sym_path: /home/tim/gits/gf180mcu_ocd_chipalooza/dependencies/gf180mcu_ocd_ip__biasgen/xschem/bias_nset.sym
** sch_path: /home/tim/gits/gf180mcu_ocd_chipalooza/dependencies/gf180mcu_ocd_ip__biasgen/xschem/bias_nset.sch
.subckt bias_nset itail ena ncasc nbias avss shld2 shld3
*.PININFO avss:B ena:I itail:B nbias:O ncasc:O shld2:B shld3:B
XM1 nbias nbias avss avss nfet_05v0 L=1.0u W=3.0u nf=1 ad='int((nf+1)/2) * W/nf * 0.18u' as='int((nf+2)/2) * W/nf * 0.18u' pd='2*int((nf+1)/2) * (W/nf + 0.18u)'
+ ps='2*int((nf+2)/2) * (W/nf + 0.18u)' nrd='0.18u / W' nrs='0.18u / W' sa=0 sb=0 sd=0 m=1 par=1
XM2 ncasc ncasc nbias avss nfet_05v0 L=1.0u W=3.0u nf=1 ad='int((nf+1)/2) * W/nf * 0.18u' as='int((nf+2)/2) * W/nf * 0.18u' pd='2*int((nf+1)/2) * (W/nf + 0.18u)'
+ ps='2*int((nf+2)/2) * (W/nf + 0.18u)' nrd='0.18u / W' nrs='0.18u / W' sa=0 sb=0 sd=0 m=1 par=1
XM3 itail ena ncasc avss nfet_05v0 L=1.0u W=3.0u nf=1 ad='int((nf+1)/2) * W/nf * 0.18u' as='int((nf+2)/2) * W/nf * 0.18u' pd='2*int((nf+1)/2) * (W/nf + 0.18u)'
+ ps='2*int((nf+2)/2) * (W/nf + 0.18u)' nrd='0.18u / W' nrs='0.18u / W' sa=0 sb=0 sd=0 m=1 par=1
.ends

* expanding   symbol:  bias_pset.sym # of pins=6
** sym_path: /home/tim/gits/gf180mcu_ocd_chipalooza/dependencies/gf180mcu_ocd_ip__biasgen/xschem/bias_pset.sym
** sch_path: /home/tim/gits/gf180mcu_ocd_chipalooza/dependencies/gf180mcu_ocd_ip__biasgen/xschem/bias_pset.sch
.subckt bias_pset avdd pbias pcasc enb itail shld3
*.PININFO pbias:B itail:B enb:I pcasc:O avdd:B shld3:B
XM1 pbias pbias avdd avdd pfet_05v0 L=1.0u W=3.0u nf=1 ad='int((nf+1)/2) * W/nf * 0.18u' as='int((nf+2)/2) * W/nf * 0.18u' pd='2*int((nf+1)/2) * (W/nf + 0.18u)'
+ ps='2*int((nf+2)/2) * (W/nf + 0.18u)' nrd='0.18u / W' nrs='0.18u / W' sa=0 sb=0 sd=0 m=1 par=1
XM2 pcasc pcasc pbias avdd pfet_05v0 L=1.0u W=3.0u nf=1 ad='int((nf+1)/2) * W/nf * 0.18u' as='int((nf+2)/2) * W/nf * 0.18u' pd='2*int((nf+1)/2) * (W/nf + 0.18u)'
+ ps='2*int((nf+2)/2) * (W/nf + 0.18u)' nrd='0.18u / W' nrs='0.18u / W' sa=0 sb=0 sd=0 m=1 par=1
XM3 itail enb pcasc avdd pfet_05v0 L=1.0u W=3.0u nf=1 ad='int((nf+1)/2) * W/nf * 0.18u' as='int((nf+2)/2) * W/nf * 0.18u' pd='2*int((nf+1)/2) * (W/nf + 0.18u)'
+ ps='2*int((nf+2)/2) * (W/nf + 0.18u)' nrd='0.18u / W' nrs='0.18u / W' sa=0 sb=0 sd=0 m=1 par=1
.ends

* expanding   symbol:  bias_amp_large.sym # of pins=7
** sym_path: /home/tim/gits/gf180mcu_ocd_chipalooza/dependencies/gf180mcu_ocd_ip__biasgen/xschem/bias_amp_large.sym
** sch_path: /home/tim/gits/gf180mcu_ocd_chipalooza/dependencies/gf180mcu_ocd_ip__biasgen/xschem/bias_amp_large.sch
.subckt bias_amp_large avdd out inn inp nbias avss ena
*.PININFO inp:I nbias:I inn:I out:O avdd:B avss:B ena:I
XM8 out outn avdd avdd pfet_05v0 L=0.50u W=10.0u nf=10 ad='int((nf+1)/2) * W/nf * 0.18u' as='int((nf+2)/2) * W/nf * 0.18u' pd='2*int((nf+1)/2) * (W/nf + 0.18u)'
+ ps='2*int((nf+2)/2) * (W/nf + 0.18u)' nrd='0.18u / W' nrs='0.18u / W' sa=0 sb=0 sd=0 m=1 par=1
XM9 net1 nbias avss avss nfet_05v0 L=0.60u W=20.0u nf=20 ad='int((nf+1)/2) * W/nf * 0.18u' as='int((nf+2)/2) * W/nf * 0.18u' pd='2*int((nf+1)/2) * (W/nf + 0.18u)'
+ ps='2*int((nf+2)/2) * (W/nf + 0.18u)' nrd='0.18u / W' nrs='0.18u / W' sa=0 sb=0 sd=0 m=1 par=1
XM1 vcom ena net1 avss nfet_05v0 L=0.60u W=20.0u nf=20 ad='int((nf+1)/2) * W/nf * 0.18u' as='int((nf+2)/2) * W/nf * 0.18u' pd='2*int((nf+1)/2) * (W/nf + 0.18u)'
+ ps='2*int((nf+2)/2) * (W/nf + 0.18u)' nrd='0.18u / W' nrs='0.18u / W' sa=0 sb=0 sd=0 m=1 par=1
XM4 outn inp vcom avss nfet_05v0 L=0.60u W=20.0u nf=20 ad='int((nf+1)/2) * W/nf * 0.18u' as='int((nf+2)/2) * W/nf * 0.18u' pd='2*int((nf+1)/2) * (W/nf + 0.18u)'
+ ps='2*int((nf+2)/2) * (W/nf + 0.18u)' nrd='0.18u / W' nrs='0.18u / W' sa=0 sb=0 sd=0 m=1 par=1
XM5 out inn vcom avss nfet_05v0 L=0.60u W=20.0u nf=20 ad='int((nf+1)/2) * W/nf * 0.18u' as='int((nf+2)/2) * W/nf * 0.18u' pd='2*int((nf+1)/2) * (W/nf + 0.18u)'
+ ps='2*int((nf+2)/2) * (W/nf + 0.18u)' nrd='0.18u / W' nrs='0.18u / W' sa=0 sb=0 sd=0 m=1 par=1
XM2 outn outn avdd avdd pfet_05v0 L=0.50u W=10.0u nf=10 ad='int((nf+1)/2) * W/nf * 0.18u' as='int((nf+2)/2) * W/nf * 0.18u' pd='2*int((nf+1)/2) * (W/nf + 0.18u)'
+ ps='2*int((nf+2)/2) * (W/nf + 0.18u)' nrd='0.18u / W' nrs='0.18u / W' sa=0 sb=0 sd=0 m=1 par=1
XM3 avdd avdd avdd avdd pfet_05v0 L=0.50u W=4.0u nf=4 ad='int((nf+1)/2) * W/nf * 0.18u' as='int((nf+2)/2) * W/nf * 0.18u' pd='2*int((nf+1)/2) * (W/nf + 0.18u)'
+ ps='2*int((nf+2)/2) * (W/nf + 0.18u)' nrd='0.18u / W' nrs='0.18u / W' sa=0 sb=0 sd=0 m=1 par=1
XM6 avss nbias avss avss nfet_05v0 L=0.60u W=6.0u nf=6 ad='int((nf+1)/2) * W/nf * 0.18u' as='int((nf+2)/2) * W/nf * 0.18u' pd='2*int((nf+1)/2) * (W/nf + 0.18u)'
+ ps='2*int((nf+2)/2) * (W/nf + 0.18u)' nrd='0.18u / W' nrs='0.18u / W' sa=0 sb=0 sd=0 m=1 par=1
.ends

* expanding   symbol:  bias_pset2.sym # of pins=7
** sym_path: /home/tim/gits/gf180mcu_ocd_chipalooza/dependencies/gf180mcu_ocd_ip__biasgen/xschem/bias_pset2.sym
** sch_path: /home/tim/gits/gf180mcu_ocd_chipalooza/dependencies/gf180mcu_ocd_ip__biasgen/xschem/bias_pset2.sch
.subckt bias_pset2 avdd pbias pcasc enb itail shld2 shld3
*.PININFO pbias:B itail:B enb:I pcasc:O avdd:B shld2:B shld3:B
XM1 pbias pbias avdd avdd pfet_05v0 L=1.0u W=3.0u nf=1 ad='int((nf+1)/2) * W/nf * 0.18u' as='int((nf+2)/2) * W/nf * 0.18u' pd='2*int((nf+1)/2) * (W/nf + 0.18u)'
+ ps='2*int((nf+2)/2) * (W/nf + 0.18u)' nrd='0.18u / W' nrs='0.18u / W' sa=0 sb=0 sd=0 m=1 par=1
XM2 pcasc pcasc pbias avdd pfet_05v0 L=1.0u W=3.0u nf=1 ad='int((nf+1)/2) * W/nf * 0.18u' as='int((nf+2)/2) * W/nf * 0.18u' pd='2*int((nf+1)/2) * (W/nf + 0.18u)'
+ ps='2*int((nf+2)/2) * (W/nf + 0.18u)' nrd='0.18u / W' nrs='0.18u / W' sa=0 sb=0 sd=0 m=1 par=1
XM3 itail enb pcasc avdd pfet_05v0 L=1.0u W=3.0u nf=1 ad='int((nf+1)/2) * W/nf * 0.18u' as='int((nf+2)/2) * W/nf * 0.18u' pd='2*int((nf+1)/2) * (W/nf + 0.18u)'
+ ps='2*int((nf+2)/2) * (W/nf + 0.18u)' nrd='0.18u / W' nrs='0.18u / W' sa=0 sb=0 sd=0 m=1 par=1
.ends
