* NGSPICE file created from pt_bias_bank3.ext - technology: gf180mcuD

.subckt pt_bias_bank3 VDD VSS TRK EN0 EN1 EN2 OUT0 OUT1 OUT2
X0 VDD TRK pm1 VDD pfet_03v3 ad=2.2p pd=10.88u as=1.3p ps=5.52u w=5u l=4u
X1 VDD TRK pm0 VDD pfet_03v3 ad=2.2p pd=10.88u as=1.3p ps=5.52u w=5u l=4u
X2 pm2 TRK VDD VDD pfet_03v3 ad=1.3p pd=5.52u as=2.2p ps=10.88u w=5u l=4u
X3 VDD TRK TRK VDD pfet_03v3 ad=2.2p pd=10.88u as=1.3p ps=5.52u w=5u l=4u
X4 pm1 TRK VDD VDD pfet_03v3 ad=1.3p pd=5.52u as=2.2p ps=10.88u w=5u l=4u
X5 OUT2 enb2 pm2 VDD pfet_03v3 ad=3.52p pd=16.88u as=3.52p ps=16.88u w=8u l=0.5u
X6 TRK TRK VDD VDD pfet_03v3 ad=1.3p pd=5.52u as=2.2p ps=10.88u w=5u l=4u
X7 enb0 EN0 VDD VDD pfet_03v3 ad=3.52p pd=16.88u as=3.52p ps=16.88u w=8u l=0.28u
X8 enb1 EN1 VDD VDD pfet_03v3 ad=3.52p pd=16.88u as=3.52p ps=16.88u w=8u l=0.28u
X9 pm0 TRK VDD VDD pfet_03v3 ad=1.3p pd=5.52u as=2.2p ps=10.88u w=5u l=4u
X10 enb2 EN2 VDD VDD pfet_03v3 ad=3.52p pd=16.88u as=3.52p ps=16.88u w=8u l=0.28u
X11 OUT0 enb0 pm0 VDD pfet_03v3 ad=3.52p pd=16.88u as=3.52p ps=16.88u w=8u l=0.5u
X12 enb1 EN1 VSS VSS nfet_03v3 ad=1.76p pd=8.88u as=1.76p ps=8.88u w=4u l=0.28u
X13 OUT1 enb1 pm1 VDD pfet_03v3 ad=3.52p pd=16.88u as=3.52p ps=16.88u w=8u l=0.5u
X14 enb0 EN0 VSS VSS nfet_03v3 ad=1.76p pd=8.88u as=1.76p ps=8.88u w=4u l=0.28u
X15 enb2 EN2 VSS VSS nfet_03v3 ad=1.76p pd=8.88u as=1.76p ps=8.88u w=4u l=0.28u
X16 VDD TRK pm2 VDD pfet_03v3 ad=2.2p pd=10.88u as=1.3p ps=5.52u w=5u l=4u
C0 enb1 OUT1 1.04426f
C1 enb2 pm2 0.45467f
C2 VDD EN0 1.15593f
C3 TRK enb2 0.09697f
C4 TRK EN2 0.27052f
C5 TRK pm0 2.2394f
C6 VDD enb1 3.57178f
C7 VDD OUT1 1.72033f
C8 pm1 enb1 0.44772f
C9 pm1 OUT1 0.7799f
C10 enb0 OUT2 0.13431f
C11 EN2 enb2 1.63557f
C12 enb0 EN1 0.16529f
C13 pm1 VDD 2.22926f
C14 OUT0 OUT2 0.04021f
C15 pm0 EN2 0.09089f
C16 OUT0 EN1 0.08331f
C17 EN0 OUT2 0.04972f
C18 EN0 EN1 5.34368f
C19 enb1 OUT2 0.14266f
C20 enb0 TRK 0.14032f
C21 OUT1 OUT2 10.4079f
C22 enb1 EN1 1.48721f
C23 EN1 OUT1 0.02719f
C24 OUT0 TRK 0.16958f
C25 VDD OUT2 2.33221f
C26 VDD EN1 1.48634f
C27 pm1 OUT2 0.09108f
C28 TRK EN0 2.89944f
C29 enb0 EN2 0.13126f
C30 enb0 pm0 0.43569f
C31 TRK enb1 0.13878f
C32 TRK OUT1 0.2166f
C33 OUT0 EN2 7.28172f
C34 OUT0 pm0 0.75373f
C35 VDD pm2 2.25422f
C36 VDD TRK 29.9174f
C37 EN0 EN2 0.03852f
C38 enb1 enb2 0.01804f
C39 pm1 TRK 2.23937f
C40 enb2 OUT1 0
C41 enb1 EN2 0.18436f
C42 EN2 OUT1 1.71241f
C43 pm0 OUT1 0.09108f
C44 EN1 OUT2 0.03976f
C45 VDD enb2 4.23289f
C46 VDD EN2 1.81138f
C47 VDD pm0 2.22931f
C48 pm1 EN2 0.13013f
C49 enb0 OUT0 0.96529f
C50 pm2 OUT2 0.81143f
C51 TRK OUT2 9.64473f
C52 TRK EN1 0.26433f
C53 enb0 EN0 1.35532f
C54 enb0 enb1 0.00971f
C55 OUT0 EN0 0.03737f
C56 enb0 OUT1 0.14034f
C57 enb2 OUT2 1.11683f
C58 OUT0 enb1 0
C59 TRK pm2 2.19098f
C60 OUT0 OUT1 7.34237f
C61 EN2 OUT2 0.51012f
C62 pm0 OUT2 0.09108f
C63 enb0 VDD 3.60938f
C64 EN2 EN1 8.38603f
C65 pm0 EN1 0.12035f
C66 OUT0 VDD 1.46074f
C67 EN0 OUT1 0.03693f
C68 OUT2 VSS 2.50555f
C69 EN2 VSS 4.07771f
C70 OUT1 VSS 1.15153f
C71 EN1 VSS 3.48365f
C72 OUT0 VSS 0.73363f
C73 EN0 VSS 3.03176f
C74 TRK VSS 8.6715f
C75 VDD VSS 91.6795f
C76 pm2 VSS 1.62046f
C77 enb2 VSS 4.65007f
C78 pm1 VSS 1.66554f
C79 enb1 VSS 5.79253f
C80 pm0 VSS 1.58503f
C81 enb0 VSS 6.7343f
.ends
