* NGSPICE file created from pt_bias_bank4.ext - technology: gf180mcuD

.subckt pt_bias_bank4 VDD VSS TRK EN0 EN1 EN2 EN3 OUT0 OUT1 OUT2 OUT3
X0 enb1 EN1 VDD VDD pfet_03v3 ad=3.52p pd=16.88u as=3.52p ps=16.88u w=8u l=0.28u
X1 enb1 EN1 VSS VSS nfet_03v3 ad=1.76p pd=8.88u as=1.76p ps=8.88u w=4u l=0.28u
X2 TRK TRK VDD VDD pfet_03v3 ad=1.3p pd=5.52u as=2.2p ps=10.88u w=5u l=4u
X3 enb0 EN0 VSS VSS nfet_03v3 ad=1.76p pd=8.88u as=1.76p ps=8.88u w=4u l=0.28u
X4 enb0 EN0 VDD VDD pfet_03v3 ad=3.52p pd=16.88u as=3.52p ps=16.88u w=8u l=0.28u
X5 VDD TRK pm3 VDD pfet_03v3 ad=2.2p pd=10.88u as=1.3p ps=5.52u w=5u l=4u
X6 enb2 EN2 VSS VSS nfet_03v3 ad=1.76p pd=8.88u as=1.76p ps=8.88u w=4u l=0.28u
X7 enb2 EN2 VDD VDD pfet_03v3 ad=3.52p pd=16.88u as=3.52p ps=16.88u w=8u l=0.28u
X8 OUT0 enb0 pm0 VDD pfet_03v3 ad=3.52p pd=16.88u as=3.52p ps=16.88u w=8u l=0.5u
X9 VDD TRK pm1 VDD pfet_03v3 ad=2.2p pd=10.88u as=1.3p ps=5.52u w=5u l=4u
X10 OUT1 enb1 pm1 VDD pfet_03v3 ad=3.52p pd=16.88u as=3.52p ps=16.88u w=8u l=0.5u
X11 enb3 EN3 VDD VDD pfet_03v3 ad=3.52p pd=16.88u as=3.52p ps=16.88u w=8u l=0.28u
X12 OUT3 enb3 pm3 VDD pfet_03v3 ad=3.52p pd=16.88u as=3.52p ps=16.88u w=8u l=0.5u
X13 OUT2 enb2 pm2 VDD pfet_03v3 ad=3.52p pd=16.88u as=3.52p ps=16.88u w=8u l=0.5u
X14 pm3 TRK VDD VDD pfet_03v3 ad=1.3p pd=5.52u as=2.2p ps=10.88u w=5u l=4u
X15 enb3 EN3 VSS VSS nfet_03v3 ad=1.76p pd=8.88u as=1.76p ps=8.88u w=4u l=0.28u
X16 VDD TRK pm2 VDD pfet_03v3 ad=2.2p pd=10.88u as=1.3p ps=5.52u w=5u l=4u
X17 pm1 TRK VDD VDD pfet_03v3 ad=1.3p pd=5.52u as=2.2p ps=10.88u w=5u l=4u
X18 pm0 TRK VDD VDD pfet_03v3 ad=1.3p pd=5.52u as=2.2p ps=10.88u w=5u l=4u
X19 VDD TRK TRK VDD pfet_03v3 ad=2.2p pd=10.88u as=1.3p ps=5.52u w=5u l=4u
X20 VDD TRK pm0 VDD pfet_03v3 ad=2.2p pd=10.88u as=1.3p ps=5.52u w=5u l=4u
X21 pm2 TRK VDD VDD pfet_03v3 ad=1.3p pd=5.52u as=2.2p ps=10.88u w=5u l=4u
C0 enb3 enb1 1.35167f
C1 enb0 EN3 0.1311f
C2 enb2 EN3 0.18973f
C3 OUT2 OUT0 0.02717f
C4 pm3 enb3 0.58812f
C5 OUT2 pm1 0.09108f
C6 TRK OUT3 1.73247f
C7 OUT3 VDD 1.78522f
C8 OUT2 pm2 0.81884f
C9 OUT2 EN0 0.03656f
C10 OUT1 TRK 0.20928f
C11 OUT1 VDD 1.7081f
C12 EN2 OUT3 0.03915f
C13 OUT1 enb1 1.11121f
C14 EN1 OUT3 0.03915f
C15 OUT1 EN2 0.08202f
C16 EN1 OUT1 0.02671f
C17 pm3 OUT3 0.74923f
C18 enb0 pm0 0.31293f
C19 EN3 pm0 0.09071f
C20 TRK OUT0 0.16295f
C21 VDD OUT0 1.45603f
C22 enb1 OUT0 0
C23 TRK pm1 2.3063f
C24 VDD pm1 2.25369f
C25 EN2 OUT0 0.06745f
C26 enb1 pm1 0.3203f
C27 TRK pm2 2.25791f
C28 enb0 enb3 0.93182f
C29 TRK EN0 2.89726f
C30 pm2 VDD 2.25968f
C31 enb2 enb3 2.4868f
C32 EN2 pm1 0.1181f
C33 EN1 OUT0 0.08331f
C34 EN0 VDD 1.15456f
C35 enb3 EN3 1.77107f
C36 EN0 EN2 0.03852f
C37 EN1 EN0 5.56318f
C38 OUT2 TRK 9.75282f
C39 EN3 OUT3 0.03915f
C40 OUT2 VDD 2.24404f
C41 enb0 OUT1 0.14032f
C42 enb2 OUT1 0
C43 OUT2 enb1 0.14264f
C44 OUT1 EN3 1.69777f
C45 OUT2 EN2 0.02671f
C46 OUT2 EN1 0.0265f
C47 enb3 pm0 0.44253f
C48 enb0 OUT0 1.03223f
C49 EN3 OUT0 7.60027f
C50 EN3 pm1 0.10275f
C51 enb0 EN0 1.35524f
C52 enb2 pm2 0.31293f
C53 TRK VDD 38.1134f
C54 TRK enb1 0.13871f
C55 pm2 EN3 0.13288f
C56 enb1 VDD 3.68894f
C57 EN0 EN3 0.03737f
C58 TRK EN2 0.25993f
C59 OUT1 pm0 0.09108f
C60 EN2 VDD 1.76067f
C61 EN2 enb1 0.16398f
C62 EN1 TRK 0.2613f
C63 EN1 VDD 1.4833f
C64 EN1 enb1 1.48713f
C65 EN1 EN2 8.60553f
C66 enb3 OUT3 3.94686f
C67 pm3 TRK 1.85663f
C68 OUT1 enb3 0
C69 pm3 VDD 2.11437f
C70 enb0 OUT2 0.1343f
C71 OUT2 enb2 1.18281f
C72 OUT2 EN3 1.20951f
C73 pm0 OUT0 0.76787f
C74 OUT1 OUT3 0.03915f
C75 enb3 OUT0 0
C76 enb3 pm1 0.30427f
C77 pm2 enb3 0.24166f
C78 enb0 TRK 0.14025f
C79 enb2 TRK 0.09697f
C80 enb0 VDD 3.72653f
C81 enb2 VDD 3.6629f
C82 enb0 enb1 0.00971f
C83 enb2 enb1 0.01804f
C84 TRK EN3 0.26749f
C85 EN3 VDD 2.34355f
C86 OUT2 pm0 0.09108f
C87 enb0 EN2 0.12524f
C88 enb2 EN2 1.61879f
C89 EN3 enb1 0.14546f
C90 OUT3 OUT0 0.03915f
C91 enb0 EN1 0.16529f
C92 EN2 EN3 11.658f
C93 OUT1 OUT0 7.66099f
C94 EN1 EN3 0.02833f
C95 OUT1 pm1 0.79403f
C96 EN0 OUT3 0.04932f
C97 OUT2 enb3 0
C98 OUT1 EN0 0.03668f
C99 TRK pm0 2.30632f
C100 VDD pm0 2.25372f
C101 OUT2 OUT3 3.75296f
C102 EN0 OUT0 0.03693f
C103 EN2 pm0 0.09089f
C104 OUT2 OUT1 10.7135f
C105 EN1 pm0 0.12035f
C106 TRK enb3 0.10933f
C107 enb3 VDD 5.27366f
C108 OUT3 VSS 2.01419f
C109 EN3 VSS 4.84507f
C110 OUT2 VSS 1.60391f
C111 EN2 VSS 3.91256f
C112 OUT1 VSS 1.1831f
C113 EN1 VSS 3.50333f
C114 OUT0 VSS 0.76648f
C115 EN0 VSS 3.13485f
C116 TRK VSS 10.9269f
C117 VDD VSS 0.11932p
C118 pm3 VSS 0.95258f
C119 enb3 VSS 10.997f
C120 pm2 VSS 1.87692f
C121 enb2 VSS 4.78878f
C122 pm1 VSS 1.79515f
C123 enb1 VSS 5.14145f
C124 pm0 VSS 1.70552f
C125 enb0 VSS 6.16037f
.ends
