* NGSPICE file created from pt_bias_bank5.ext - technology: gf180mcuD

.subckt pt_bias_bank5 VDD VSS TRK EN0 EN1 EN2 EN3 EN4 OUT0 OUT1 OUT2 OUT3 OUT4
X0 VDD TRK pm2 VDD pfet_03v3 ad=2.2p pd=10.88u as=1.3p ps=5.52u w=5u l=4u
X1 VDD TRK pm1 VDD pfet_03v3 ad=2.2p pd=10.88u as=1.3p ps=5.52u w=5u l=4u
X2 VDD TRK pm0 VDD pfet_03v3 ad=2.2p pd=10.88u as=1.3p ps=5.52u w=5u l=4u
X3 pm2 TRK VDD VDD pfet_03v3 ad=1.3p pd=5.52u as=2.2p ps=10.88u w=5u l=4u
X4 VDD TRK TRK VDD pfet_03v3 ad=2.2p pd=10.88u as=1.3p ps=5.52u w=5u l=4u
X5 pm1 TRK VDD VDD pfet_03v3 ad=1.3p pd=5.52u as=2.2p ps=10.88u w=5u l=4u
X6 enb1 EN1 VSS VSS nfet_03v3 ad=1.76p pd=8.88u as=1.76p ps=8.88u w=4u l=0.28u
X7 TRK TRK VDD VDD pfet_03v3 ad=1.3p pd=5.52u as=2.2p ps=10.88u w=5u l=4u
X8 enb0 EN0 VDD VDD pfet_03v3 ad=3.52p pd=16.88u as=3.52p ps=16.88u w=8u l=0.28u
X9 enb1 EN1 VDD VDD pfet_03v3 ad=3.52p pd=16.88u as=3.52p ps=16.88u w=8u l=0.28u
X10 VDD TRK pm4 VDD pfet_03v3 ad=2.2p pd=10.88u as=1.3p ps=5.52u w=5u l=4u
X11 enb2 EN2 VDD VDD pfet_03v3 ad=3.52p pd=16.88u as=3.52p ps=16.88u w=8u l=0.28u
X12 OUT0 enb0 pm0 VDD pfet_03v3 ad=3.52p pd=16.88u as=3.52p ps=16.88u w=8u l=0.5u
X13 enb0 EN0 VSS VSS nfet_03v3 ad=1.76p pd=8.88u as=1.76p ps=8.88u w=4u l=0.28u
X14 enb3 EN3 VDD VDD pfet_03v3 ad=3.52p pd=16.88u as=3.52p ps=16.88u w=8u l=0.28u
X15 OUT4 enb4 pm4 VDD pfet_03v3 ad=3.52p pd=16.88u as=3.52p ps=16.88u w=8u l=0.5u
X16 pm0 TRK VDD VDD pfet_03v3 ad=1.3p pd=5.52u as=2.2p ps=10.88u w=5u l=4u
X17 VDD TRK pm3 VDD pfet_03v3 ad=2.2p pd=10.88u as=1.3p ps=5.52u w=5u l=4u
X18 enb3 EN3 VSS VSS nfet_03v3 ad=1.76p pd=8.88u as=1.76p ps=8.88u w=4u l=0.28u
X19 enb4 EN4 VDD VDD pfet_03v3 ad=3.52p pd=16.88u as=3.52p ps=16.88u w=8u l=0.28u
X20 OUT1 enb1 pm1 VDD pfet_03v3 ad=3.52p pd=16.88u as=3.52p ps=16.88u w=8u l=0.5u
X21 enb2 EN2 VSS VSS nfet_03v3 ad=1.76p pd=8.88u as=1.76p ps=8.88u w=4u l=0.28u
X22 OUT3 enb3 pm3 VDD pfet_03v3 ad=3.52p pd=16.88u as=3.52p ps=16.88u w=8u l=0.5u
X23 OUT2 enb2 pm2 VDD pfet_03v3 ad=3.52p pd=16.88u as=3.52p ps=16.88u w=8u l=0.5u
X24 pm3 TRK VDD VDD pfet_03v3 ad=1.3p pd=5.52u as=2.2p ps=10.88u w=5u l=4u
X25 enb4 EN4 VSS VSS nfet_03v3 ad=1.76p pd=8.88u as=1.76p ps=8.88u w=4u l=0.28u
X26 pm4 TRK VDD VDD pfet_03v3 ad=1.3p pd=5.52u as=2.2p ps=10.88u w=5u l=4u
C0 OUT4 EN1 0.03915f
C1 EN2 enb2 1.61879f
C2 TRK enb3 0.16019f
C3 OUT2 EN1 0.0265f
C4 VDD OUT3 1.31808f
C5 OUT4 enb4 0.91401f
C6 EN2 EN0 0.03852f
C7 TRK pm2 2.25791f
C8 enb1 VDD 3.68894f
C9 enb0 OUT2 0.1343f
C10 OUT2 pm0 0.09108f
C11 enb0 EN1 0.16529f
C12 OUT3 pm3 0.72588f
C13 EN1 pm0 0.12035f
C14 OUT1 enb2 0
C15 TRK EN2 0.25993f
C16 EN3 VDD 2.34185f
C17 EN4 OUT4 0.71992f
C18 enb0 pm0 0.31293f
C19 OUT1 EN0 0.03668f
C20 OUT2 EN4 0.03906f
C21 EN4 EN1 0.02611f
C22 enb1 pm1 0.3203f
C23 EN4 enb4 1.36745f
C24 enb3 OUT0 0
C25 enb0 EN4 0
C26 TRK OUT1 0.19136f
C27 EN3 pm1 0.10275f
C28 OUT3 OUT4 10.0211f
C29 OUT2 OUT3 3.73991f
C30 OUT3 EN1 0.02611f
C31 EN2 OUT0 0.06745f
C32 OUT3 enb4 0
C33 enb1 OUT2 0.14264f
C34 enb1 EN1 1.48713f
C35 enb1 enb4 0
C36 EN3 OUT4 0.03915f
C37 enb0 enb1 0.00971f
C38 EN3 OUT2 1.20951f
C39 EN3 EN1 0.02833f
C40 OUT1 OUT0 7.73416f
C41 OUT3 EN4 2.64633f
C42 enb0 EN3 0.1311f
C43 EN3 pm0 0.09071f
C44 pm2 enb3 0.24166f
C45 VDD enb2 3.6629f
C46 EN3 EN4 3.23105f
C47 VDD EN0 1.15456f
C48 TRK VDD 44.7284f
C49 OUT1 enb3 0
C50 EN3 OUT3 0.02611f
C51 TRK pm3 2.03859f
C52 EN3 enb1 0.14546f
C53 TRK pm4 1.99017f
C54 TRK pm1 2.3063f
C55 OUT1 EN2 0.08202f
C56 OUT2 enb2 1.18281f
C57 EN0 OUT4 0.04932f
C58 OUT2 EN0 0.03656f
C59 VDD OUT0 1.45435f
C60 EN0 EN1 5.70952f
C61 TRK OUT4 4.34792f
C62 enb0 EN0 1.35524f
C63 TRK OUT2 9.81079f
C64 TRK EN1 0.2613f
C65 TRK enb4 0.09707f
C66 enb0 TRK 0.14025f
C67 EN0 EN4 0.03627f
C68 TRK pm0 2.3237f
C69 TRK EN4 0.90296f
C70 OUT0 OUT4 0.03915f
C71 VDD enb3 3.6735f
C72 OUT2 OUT0 0.02717f
C73 OUT3 EN0 0.03627f
C74 OUT0 EN1 0.08331f
C75 enb1 enb2 0.01804f
C76 pm2 VDD 2.25968f
C77 enb3 pm3 0.4783f
C78 enb0 OUT0 1.03223f
C79 OUT0 pm0 0.76787f
C80 pm4 enb3 0.0029f
C81 TRK OUT3 0.11683f
C82 EN3 enb2 0.18973f
C83 pm1 enb3 0.30427f
C84 EN2 VDD 1.76067f
C85 EN3 EN0 0.03737f
C86 TRK enb1 0.13871f
C87 EN4 OUT0 3.37137f
C88 EN3 TRK 0.28867f
C89 EN2 pm1 0.1181f
C90 OUT1 VDD 1.70727f
C91 enb3 OUT4 3.65105f
C92 OUT2 enb3 0
C93 OUT3 OUT0 0.02611f
C94 enb3 enb4 0.01774f
C95 OUT1 pm1 0.79403f
C96 pm2 OUT2 0.81884f
C97 enb0 enb3 0.93182f
C98 enb1 OUT0 0
C99 enb3 pm0 0.44253f
C100 EN2 OUT4 0.03915f
C101 EN2 OUT2 0.02671f
C102 EN2 EN1 8.75186f
C103 EN3 OUT0 4.4765f
C104 enb3 EN4 0.13729f
C105 enb0 EN2 0.12524f
C106 EN2 pm0 0.09089f
C107 OUT1 OUT4 0.03915f
C108 OUT1 OUT2 10.7867f
C109 OUT1 EN1 0.02671f
C110 EN2 EN4 0.02611f
C111 enb0 OUT1 0.14032f
C112 OUT3 enb3 0.78032f
C113 OUT1 pm0 0.09108f
C114 enb1 enb3 1.35167f
C115 TRK enb2 0.09697f
C116 OUT1 EN4 0.064f
C117 TRK EN0 2.89726f
C118 EN2 OUT3 0.02611f
C119 EN3 enb3 1.77107f
C120 VDD pm3 2.15602f
C121 enb1 EN2 0.16398f
C122 EN3 pm2 0.13288f
C123 pm4 VDD 2.17863f
C124 pm1 VDD 2.25369f
C125 OUT1 OUT3 0.02611f
C126 EN3 EN2 11.8044f
C127 OUT1 enb1 1.11121f
C128 EN0 OUT0 0.03693f
C129 EN3 OUT1 1.69777f
C130 VDD OUT4 1.99718f
C131 VDD OUT2 2.2428f
C132 TRK OUT0 0.14118f
C133 VDD EN1 1.4833f
C134 VDD enb4 4.15947f
C135 pm3 OUT4 0.09125f
C136 enb0 VDD 3.72701f
C137 VDD pm0 2.26406f
C138 pm4 OUT4 0.773f
C139 pm1 OUT2 0.09108f
C140 pm4 enb4 0.49107f
C141 VDD EN4 1.29712f
C142 enb2 enb3 2.4868f
C143 pm4 pm0 0.00191f
C144 EN4 pm3 0.1226f
C145 pm2 enb2 0.31293f
C146 OUT2 OUT4 0.03915f
C147 OUT4 VSS 2.1716f
C148 EN4 VSS 3.87297f
C149 OUT3 VSS 0.75975f
C150 EN3 VSS 4.86408f
C151 OUT2 VSS 1.60345f
C152 EN2 VSS 3.92454f
C153 OUT1 VSS 1.18198f
C154 EN1 VSS 3.51532f
C155 OUT0 VSS 0.76486f
C156 EN0 VSS 3.20256f
C157 TRK VSS 16.2418f
C158 VDD VSS 0.14904p
C159 pm4 VSS 1.29461f
C160 enb4 VSS 4.26197f
C161 pm3 VSS 1.32766f
C162 enb3 VSS 12.9269f
C163 pm2 VSS 1.87692f
C164 enb2 VSS 4.78878f
C165 pm1 VSS 1.79515f
C166 enb1 VSS 5.14124f
C167 pm0 VSS 1.68096f
C168 enb0 VSS 6.16037f
.ends
