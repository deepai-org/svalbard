* pt_bias_bank5: generated by analog/rf_tx/circuits.py
* Island mirror bank with 5 switched 10 uA source outputs on the island rail (VDD = VISL).
* TRK is the PMOS diode node (trunk from pt_bias_root, or ATB force).
.subckt pt_bias_bank5 VDD VSS TRK EN0 EN1 EN2 EN3 EN4 OUT0 OUT1 OUT2 OUT3 OUT4
XPREF_f0 TRK TRK VDD VDD pfet_03v3 w=5u l=4u ad=2.2p as=2.2p pd=10.88u ps=10.88u
XPREF_f1 TRK TRK VDD VDD pfet_03v3 w=5u l=4u ad=2.2p as=2.2p pd=10.88u ps=10.88u
XI0_N enb0 EN0 VSS VSS nfet_03v3 w=4u l=0.28u ad=1.76p as=1.76p pd=8.88u ps=8.88u
XI0_P enb0 EN0 VDD VDD pfet_03v3 w=8u l=0.28u ad=3.52p as=3.52p pd=16.88u ps=16.88u
XPM0_f0 pm0 TRK VDD VDD pfet_03v3 w=5u l=4u ad=2.2p as=2.2p pd=10.88u ps=10.88u
XPM0_f1 pm0 TRK VDD VDD pfet_03v3 w=5u l=4u ad=2.2p as=2.2p pd=10.88u ps=10.88u
XPS0 OUT0 enb0 pm0 VDD pfet_03v3 w=8u l=0.5u ad=3.52p as=3.52p pd=16.88u ps=16.88u
XI1_N enb1 EN1 VSS VSS nfet_03v3 w=4u l=0.28u ad=1.76p as=1.76p pd=8.88u ps=8.88u
XI1_P enb1 EN1 VDD VDD pfet_03v3 w=8u l=0.28u ad=3.52p as=3.52p pd=16.88u ps=16.88u
XPM1_f0 pm1 TRK VDD VDD pfet_03v3 w=5u l=4u ad=2.2p as=2.2p pd=10.88u ps=10.88u
XPM1_f1 pm1 TRK VDD VDD pfet_03v3 w=5u l=4u ad=2.2p as=2.2p pd=10.88u ps=10.88u
XPS1 OUT1 enb1 pm1 VDD pfet_03v3 w=8u l=0.5u ad=3.52p as=3.52p pd=16.88u ps=16.88u
XI2_N enb2 EN2 VSS VSS nfet_03v3 w=4u l=0.28u ad=1.76p as=1.76p pd=8.88u ps=8.88u
XI2_P enb2 EN2 VDD VDD pfet_03v3 w=8u l=0.28u ad=3.52p as=3.52p pd=16.88u ps=16.88u
XPM2_f0 pm2 TRK VDD VDD pfet_03v3 w=5u l=4u ad=2.2p as=2.2p pd=10.88u ps=10.88u
XPM2_f1 pm2 TRK VDD VDD pfet_03v3 w=5u l=4u ad=2.2p as=2.2p pd=10.88u ps=10.88u
XPS2 OUT2 enb2 pm2 VDD pfet_03v3 w=8u l=0.5u ad=3.52p as=3.52p pd=16.88u ps=16.88u
XI3_N enb3 EN3 VSS VSS nfet_03v3 w=4u l=0.28u ad=1.76p as=1.76p pd=8.88u ps=8.88u
XI3_P enb3 EN3 VDD VDD pfet_03v3 w=8u l=0.28u ad=3.52p as=3.52p pd=16.88u ps=16.88u
XPM3_f0 pm3 TRK VDD VDD pfet_03v3 w=5u l=4u ad=2.2p as=2.2p pd=10.88u ps=10.88u
XPM3_f1 pm3 TRK VDD VDD pfet_03v3 w=5u l=4u ad=2.2p as=2.2p pd=10.88u ps=10.88u
XPS3 OUT3 enb3 pm3 VDD pfet_03v3 w=8u l=0.5u ad=3.52p as=3.52p pd=16.88u ps=16.88u
XI4_N enb4 EN4 VSS VSS nfet_03v3 w=4u l=0.28u ad=1.76p as=1.76p pd=8.88u ps=8.88u
XI4_P enb4 EN4 VDD VDD pfet_03v3 w=8u l=0.28u ad=3.52p as=3.52p pd=16.88u ps=16.88u
XPM4_f0 pm4 TRK VDD VDD pfet_03v3 w=5u l=4u ad=2.2p as=2.2p pd=10.88u ps=10.88u
XPM4_f1 pm4 TRK VDD VDD pfet_03v3 w=5u l=4u ad=2.2p as=2.2p pd=10.88u ps=10.88u
XPS4 OUT4 enb4 pm4 VDD pfet_03v3 w=8u l=0.5u ad=3.52p as=3.52p pd=16.88u ps=16.88u
.ends pt_bias_bank5
