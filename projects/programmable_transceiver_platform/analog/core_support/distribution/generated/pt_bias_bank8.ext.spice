* NGSPICE file created from pt_bias_bank8.ext - technology: gf180mcuD

.subckt pt_bias_bank8 VDD VSS TRK EN0 EN1 EN2 EN3 EN4 EN5 EN6 EN7 OUT0 OUT1 OUT2 OUT3
+ OUT4 OUT5 OUT6 OUT7
X0 VDD TRK pm1 VDD pfet_03v3 ad=2.2p pd=10.88u as=1.3p ps=5.52u w=5u l=4u
X1 enb2 EN2 VDD VDD pfet_03v3 ad=3.52p pd=16.88u as=3.52p ps=16.88u w=8u l=0.28u
X2 TRK TRK VDD VDD pfet_03v3 ad=1.3p pd=5.52u as=2.2p ps=10.88u w=5u l=4u
X3 VDD TRK pm0 VDD pfet_03v3 ad=2.2p pd=10.88u as=1.3p ps=5.52u w=5u l=4u
X4 pm2 TRK VDD VDD pfet_03v3 ad=1.3p pd=5.52u as=2.2p ps=10.88u w=5u l=4u
X5 VDD TRK pm3 VDD pfet_03v3 ad=2.2p pd=10.88u as=1.3p ps=5.52u w=5u l=4u
X6 OUT0 enb0 pm0 VDD pfet_03v3 ad=3.52p pd=16.88u as=3.52p ps=16.88u w=8u l=0.5u
X7 pm1 TRK VDD VDD pfet_03v3 ad=1.3p pd=5.52u as=2.2p ps=10.88u w=5u l=4u
X8 pm0 TRK VDD VDD pfet_03v3 ad=1.3p pd=5.52u as=2.2p ps=10.88u w=5u l=4u
X9 VDD TRK pm4 VDD pfet_03v3 ad=2.2p pd=10.88u as=1.3p ps=5.52u w=5u l=4u
X10 OUT1 enb1 pm1 VDD pfet_03v3 ad=3.52p pd=16.88u as=3.52p ps=16.88u w=8u l=0.5u
X11 enb3 EN3 VDD VDD pfet_03v3 ad=3.52p pd=16.88u as=3.52p ps=16.88u w=8u l=0.28u
X12 VDD TRK pm6 VDD pfet_03v3 ad=2.2p pd=10.88u as=1.3p ps=5.52u w=5u l=4u
X13 enb0 EN0 VDD VDD pfet_03v3 ad=3.52p pd=16.88u as=3.52p ps=16.88u w=8u l=0.28u
X14 VDD TRK pm5 VDD pfet_03v3 ad=2.2p pd=10.88u as=1.3p ps=5.52u w=5u l=4u
X15 pm4 TRK VDD VDD pfet_03v3 ad=1.3p pd=5.52u as=2.2p ps=10.88u w=5u l=4u
X16 OUT2 enb2 pm2 VDD pfet_03v3 ad=3.52p pd=16.88u as=3.52p ps=16.88u w=8u l=0.5u
X17 OUT7 enb7 pm7 VDD pfet_03v3 ad=3.52p pd=16.88u as=3.52p ps=16.88u w=8u l=0.5u
X18 enb0 EN0 VSS VSS nfet_03v3 ad=1.76p pd=8.88u as=1.76p ps=8.88u w=4u l=0.28u
X19 pm5 TRK VDD VDD pfet_03v3 ad=1.3p pd=5.52u as=2.2p ps=10.88u w=5u l=4u
X20 enb6 EN6 VDD VDD pfet_03v3 ad=3.52p pd=16.88u as=3.52p ps=16.88u w=8u l=0.28u
X21 pm3 TRK VDD VDD pfet_03v3 ad=1.3p pd=5.52u as=2.2p ps=10.88u w=5u l=4u
X22 enb2 EN2 VSS VSS nfet_03v3 ad=1.76p pd=8.88u as=1.76p ps=8.88u w=4u l=0.28u
X23 enb7 EN7 VDD VDD pfet_03v3 ad=3.52p pd=16.88u as=3.52p ps=16.88u w=8u l=0.28u
X24 enb1 EN1 VSS VSS nfet_03v3 ad=1.76p pd=8.88u as=1.76p ps=8.88u w=4u l=0.28u
X25 enb3 EN3 VSS VSS nfet_03v3 ad=1.76p pd=8.88u as=1.76p ps=8.88u w=4u l=0.28u
X26 OUT3 enb3 pm3 VDD pfet_03v3 ad=3.52p pd=16.88u as=3.52p ps=16.88u w=8u l=0.5u
X27 enb6 EN6 VSS VSS nfet_03v3 ad=1.76p pd=8.88u as=1.76p ps=8.88u w=4u l=0.28u
X28 pm6 TRK VDD VDD pfet_03v3 ad=1.3p pd=5.52u as=2.2p ps=10.88u w=5u l=4u
X29 pm7 TRK VDD VDD pfet_03v3 ad=1.3p pd=5.52u as=2.2p ps=10.88u w=5u l=4u
X30 enb5 EN5 VSS VSS nfet_03v3 ad=1.76p pd=8.88u as=1.76p ps=8.88u w=4u l=0.28u
X31 VDD TRK TRK VDD pfet_03v3 ad=2.2p pd=10.88u as=1.3p ps=5.52u w=5u l=4u
X32 VDD TRK pm2 VDD pfet_03v3 ad=2.2p pd=10.88u as=1.3p ps=5.52u w=5u l=4u
X33 OUT5 enb5 pm5 VDD pfet_03v3 ad=3.52p pd=16.88u as=3.52p ps=16.88u w=8u l=0.5u
X34 OUT4 enb4 pm4 VDD pfet_03v3 ad=3.52p pd=16.88u as=3.52p ps=16.88u w=8u l=0.5u
X35 enb7 EN7 VSS VSS nfet_03v3 ad=1.76p pd=8.88u as=1.76p ps=8.88u w=4u l=0.28u
X36 enb4 EN4 VSS VSS nfet_03v3 ad=1.76p pd=8.88u as=1.76p ps=8.88u w=4u l=0.28u
X37 OUT6 enb6 pm6 VDD pfet_03v3 ad=3.52p pd=16.88u as=3.52p ps=16.88u w=8u l=0.5u
X38 enb5 EN5 VDD VDD pfet_03v3 ad=3.52p pd=16.88u as=3.52p ps=16.88u w=8u l=0.28u
X39 enb4 EN4 VDD VDD pfet_03v3 ad=3.52p pd=16.88u as=3.52p ps=16.88u w=8u l=0.28u
X40 VDD TRK pm7 VDD pfet_03v3 ad=2.2p pd=10.88u as=1.3p ps=5.52u w=5u l=4u
X41 enb1 EN1 VDD VDD pfet_03v3 ad=3.52p pd=16.88u as=3.52p ps=16.88u w=8u l=0.28u
C0 enb1 OUT0 0
C1 VDD pm6 2.28407f
C2 OUT6 enb6 1.25196f
C3 enb4 enb3 0.01774f
C4 TRK pm0 2.3237f
C5 TRK OUT5 0.17722f
C6 pm4 enb7 0.30893f
C7 enb4 EN5 0.16529f
C8 pm5 EN6 0.1181f
C9 VDD OUT2 2.23814f
C10 enb3 pm0 0.44253f
C11 OUT5 enb3 0.08266f
C12 OUT2 OUT7 0.03915f
C13 enb4 enb1 0
C14 EN5 OUT5 0.0265f
C15 enb6 enb7 2.49513f
C16 EN3 OUT2 1.20951f
C17 OUT6 EN4 0.03645f
C18 pm4 enb4 0.33685f
C19 enb5 EN7 0.15127f
C20 TRK VDD 71.6661f
C21 EN4 OUT4 0.03668f
C22 TRK OUT7 2.06599f
C23 EN4 EN1 0.02611f
C24 pm4 pm0 0.00191f
C25 EN3 TRK 0.35221f
C26 pm4 OUT5 0.09108f
C27 OUT3 EN4 0.10543f
C28 EN2 OUT2 0.02671f
C29 VDD pm1 2.26651f
C30 EN6 OUT2 0
C31 enb3 VDD 4.06604f
C32 OUT2 EN0 0.03656f
C33 enb2 OUT2 1.18281f
C34 EN4 OUT0 0
C35 enb3 OUT7 5.11557f
C36 EN5 VDD 1.55243f
C37 EN5 OUT7 0.02611f
C38 EN3 pm1 0.10275f
C39 EN3 enb3 1.77107f
C40 enb0 EN1 0.16529f
C41 OUT5 enb6 0
C42 EN3 EN5 0.03411f
C43 OUT6 OUT1 0.02611f
C44 TRK EN2 0.25993f
C45 TRK pm3 2.38307f
C46 VDD enb1 3.69087f
C47 TRK EN6 0.22487f
C48 TRK EN0 2.89726f
C49 enb2 TRK 0.10314f
C50 enb4 EN4 1.35524f
C51 enb0 OUT0 1.03223f
C52 OUT1 OUT4 0.02611f
C53 EN3 enb1 0.14546f
C54 pm4 VDD 2.27813f
C55 OUT1 EN1 0.02671f
C56 EN2 pm1 0.1181f
C57 enb3 pm3 0.33104f
C58 enb3 EN6 0.07988f
C59 OUT1 OUT3 0.02611f
C60 enb2 enb3 2.4868f
C61 EN5 EN2 0.02611f
C62 EN5 pm3 0.09114f
C63 EN5 EN6 14.948f
C64 OUT5 EN4 0.03656f
C65 OUT1 OUT0 8.02682f
C66 pm5 TRK 2.37319f
C67 EN5 EN0 0.03627f
C68 enb6 VDD 3.78009f
C69 EN2 enb1 0.16398f
C70 enb2 enb1 0.01804f
C71 pm5 pm1 0.00291f
C72 pm5 enb3 0.0029f
C73 OUT6 EN7 0.96054f
C74 enb0 pm0 0.31293f
C75 pm4 EN6 0.09089f
C76 TRK pm6 2.32482f
C77 EN7 OUT4 1.71967f
C78 VDD EN4 1.2733f
C79 EN7 EN1 0.02611f
C80 OUT7 EN4 0.03627f
C81 enb5 OUT6 0.14372f
C82 OUT1 pm0 0.09108f
C83 OUT1 OUT5 0.02611f
C84 EN7 OUT3 3.02313f
C85 EN7 enb7 1.6361f
C86 enb3 pm6 0.0029f
C87 TRK OUT2 10.1034f
C88 EN3 EN4 3.23105f
C89 enb6 EN6 1.61879f
C90 EN7 OUT0 3.37137f
C91 enb5 OUT4 0
C92 enb0 VDD 3.72701f
C93 OUT2 pm1 0.09108f
C94 enb3 OUT2 0
C95 enb5 enb7 1.35167f
C96 EN5 OUT2 0
C97 EN3 enb0 0.1311f
C98 enb4 EN7 0.14546f
C99 EN2 EN4 0.02611f
C100 pm3 EN4 0.1226f
C101 EN6 EN4 0.03852f
C102 EN0 EN4 0.03627f
C103 OUT1 VDD 1.70365f
C104 OUT2 enb1 0.14264f
C105 OUT1 OUT7 0.03915f
C106 TRK pm1 2.33274f
C107 TRK enb3 0.15832f
C108 EN3 OUT1 1.69777f
C109 TRK EN5 0.20491f
C110 OUT5 EN7 1.21394f
C111 enb5 enb4 0.01804f
C112 enb0 EN2 0.12524f
C113 enb6 pm6 0.32712f
C114 enb3 pm1 0.30427f
C115 enb0 EN0 1.35524f
C116 pm2 VDD 2.27559f
C117 TRK enb1 0.13871f
C118 EN5 enb3 0.0799f
C119 enb5 OUT5 1.18278f
C120 pm2 EN3 0.13288f
C121 pm7 enb7 0.58491f
C122 OUT1 EN2 0.08202f
C123 pm4 TRK 2.37323f
C124 OUT1 EN6 0
C125 enb2 OUT1 0
C126 OUT1 EN0 0.03668f
C127 enb1 pm1 0.3203f
C128 enb3 enb1 1.35167f
C129 EN5 enb1 0
C130 VDD EN7 2.06932f
C131 OUT6 OUT4 0.02717f
C132 EN7 OUT7 1.15769f
C133 pm4 enb3 0.0029f
C134 TRK enb6 0.09691f
C135 pm4 EN5 0.12035f
C136 EN3 EN7 0.03411f
C137 OUT6 EN1 0.02611f
C138 OUT2 EN4 0
C139 enb2 pm2 0.31293f
C140 OUT6 OUT3 0.0266f
C141 OUT6 enb7 0
C142 enb5 VDD 3.80523f
C143 OUT4 EN1 0.02611f
C144 OUT6 OUT0 0.02611f
C145 enb6 enb3 0.00861f
C146 OUT3 OUT4 10.8306f
C147 OUT0 OUT4 0.02611f
C148 OUT3 EN1 0.02611f
C149 EN2 EN7 0.02611f
C150 pm3 EN7 0.09071f
C151 TRK EN4 0.79013f
C152 EN6 EN7 18.0116f
C153 enb0 OUT2 0.1343f
C154 EN7 EN0 0.03627f
C155 OUT0 EN1 0.08331f
C156 enb4 OUT6 0.13423f
C157 OUT3 OUT0 0.02611f
C158 enb3 EN4 0.13114f
C159 enb4 OUT4 1.11117f
C160 OUT1 OUT2 11.0794f
C161 enb5 EN6 0.16398f
C162 EN5 EN4 11.9057f
C163 TRK enb0 0.14025f
C164 enb5 enb2 0
C165 pm5 EN7 0.10741f
C166 pm2 pm6 0.00419f
C167 OUT6 OUT5 16.9356f
C168 pm7 VDD 2.1387f
C169 enb4 OUT3 0
C170 enb4 enb7 0.93148f
C171 pm7 OUT7 0.76112f
C172 OUT5 OUT4 13.8831f
C173 enb0 enb3 0.93182f
C174 TRK OUT1 0.19126f
C175 pm0 EN1 0.12035f
C176 pm2 OUT2 0.81884f
C177 OUT5 EN1 0.02611f
C178 enb5 pm5 0.33685f
C179 OUT5 OUT3 0.02717f
C180 pm6 EN7 0.13518f
C181 OUT5 enb7 0
C182 pm0 OUT0 0.76787f
C183 OUT5 OUT0 0.02611f
C184 OUT1 pm1 0.79403f
C185 OUT1 enb3 0
C186 enb0 enb1 0.00971f
C187 OUT6 VDD 2.31922f
C188 EN5 OUT1 0
C189 pm2 TRK 2.29536f
C190 OUT6 OUT7 9.28382f
C191 pm7 pm3 0.00118f
C192 OUT2 EN7 0.03906f
C193 VDD OUT4 1.54785f
C194 OUT6 EN3 0.02611f
C195 OUT7 OUT4 0.02611f
C196 enb4 OUT5 0.14264f
C197 OUT1 enb1 1.11121f
C198 VDD EN1 1.4833f
C199 pm2 enb3 0.24166f
C200 EN3 OUT4 0.02611f
C201 OUT7 EN1 0.03915f
C202 VDD OUT3 1.30013f
C203 VDD enb7 5.61908f
C204 TRK EN7 1.12817f
C205 OUT3 OUT7 0.02611f
C206 OUT7 enb7 2.14001f
C207 EN3 EN1 0.02833f
C208 VDD OUT0 1.4525f
C209 OUT7 OUT0 0.03915f
C210 EN3 OUT3 0.02611f
C211 OUT6 EN2 0.02611f
C212 OUT6 pm3 0.09108f
C213 OUT6 EN6 0.02647f
C214 EN3 OUT0 4.76917f
C215 OUT6 EN0 0.03627f
C216 enb3 EN7 0.07959f
C217 EN2 OUT4 0.02611f
C218 pm3 OUT4 0.09108f
C219 enb5 TRK 0.13861f
C220 EN6 OUT4 0.06745f
C221 EN5 EN7 0.03907f
C222 EN0 OUT4 0.03627f
C223 enb4 VDD 3.84143f
C224 EN2 EN1 9.26403f
C225 EN6 EN1 0.02611f
C226 enb0 EN4 0
C227 EN0 EN1 6.22169f
C228 EN2 OUT3 0.02611f
C229 pm3 OUT3 0.76787f
C230 pm3 enb7 0.44483f
C231 EN6 OUT3 0.07819f
C232 pm5 OUT6 0.09108f
C233 OUT3 EN0 0.03627f
C234 enb5 enb3 0.00803f
C235 EN2 OUT0 0.06745f
C236 EN6 OUT0 0
C237 VDD pm0 2.26406f
C238 enb5 EN5 1.48713f
C239 EN0 OUT0 0.03693f
C240 OUT5 VDD 1.78206f
C241 OUT5 OUT7 0.02611f
C242 pm4 EN7 0.10275f
C243 OUT1 EN4 0
C244 EN3 pm0 0.09071f
C245 EN3 OUT5 0.02611f
C246 pm5 enb7 0.25369f
C247 OUT6 pm6 0.83527f
C248 enb4 EN6 0.12524f
C249 enb6 EN7 0.19246f
C250 TRK pm7 1.92359f
C251 OUT1 enb0 0.14032f
C252 EN2 pm0 0.09089f
C253 OUT6 OUT2 0.02611f
C254 OUT5 EN2 0.02611f
C255 OUT5 pm3 0.09108f
C256 OUT5 EN6 0.08202f
C257 VDD OUT7 1.8968f
C258 OUT5 EN0 0.03627f
C259 pm6 enb7 0.21488f
C260 enb5 enb6 0.02638f
C261 OUT2 OUT4 0.02611f
C262 EN3 VDD 2.34185f
C263 EN3 OUT7 0.03915f
C264 OUT2 EN1 0.0265f
C265 EN7 EN4 0.04811f
C266 OUT6 TRK 10.4008f
C267 OUT2 OUT3 3.73991f
C268 pm5 OUT5 0.81283f
C269 OUT2 OUT0 0.02717f
C270 TRK OUT4 0.12861f
C271 EN2 VDD 1.76067f
C272 VDD pm3 2.28651f
C273 OUT6 enb3 0.08307f
C274 EN6 VDD 1.82885f
C275 TRK EN1 0.2613f
C276 EN2 OUT7 0.03915f
C277 VDD EN0 1.15456f
C278 enb2 VDD 3.66567f
C279 EN6 OUT7 0.02611f
C280 OUT6 EN5 0.02635f
C281 TRK OUT3 0.0948f
C282 EN0 OUT7 0.04932f
C283 TRK enb7 0.11188f
C284 EN3 EN2 12.3165f
C285 enb3 OUT4 0.08849f
C286 EN3 EN6 0.03411f
C287 TRK OUT0 0.14105f
C288 EN3 EN0 0.03737f
C289 enb2 EN3 0.18973f
C290 EN5 OUT4 0.08331f
C291 OUT1 EN7 0.064f
C292 EN5 EN1 0.02611f
C293 enb3 OUT3 0.98026f
C294 enb3 enb7 0.509f
C295 pm5 VDD 2.2781f
C296 EN5 OUT3 0.07829f
C297 enb3 OUT0 0
C298 pm0 OUT2 0.09108f
C299 pm4 OUT6 0.09108f
C300 OUT5 OUT2 0.02611f
C301 EN5 OUT0 0
C302 enb4 TRK 0.13871f
C303 EN2 EN6 0.02611f
C304 EN6 pm3 0.09089f
C305 enb1 EN1 1.48713f
C306 EN2 EN0 0.03852f
C307 enb2 EN2 1.61879f
C308 enb2 EN6 0.00154f
C309 EN6 EN0 0.03627f
C310 pm4 OUT4 0.79403f
C311 OUT7 VSS 2.45089f
C312 EN7 VSS 6.79458f
C313 OUT6 VSS 1.91251f
C314 EN6 VSS 4.1593f
C315 OUT5 VSS 1.49993f
C316 EN5 VSS 3.75037f
C317 OUT4 VSS 1.09537f
C318 EN4 VSS 3.90212f
C319 OUT3 VSS 0.83595f
C320 EN3 VSS 4.9271f
C321 OUT2 VSS 1.62742f
C322 EN2 VSS 3.96647f
C323 OUT1 VSS 1.20592f
C324 EN1 VSS 3.55725f
C325 OUT0 VSS 0.78873f
C326 EN0 VSS 3.43955f
C327 TRK VSS 21.7794f
C328 VDD VSS 0.22857p
C329 pm7 VSS 1.007f
C330 enb7 VSS 10.7313f
C331 pm6 VSS 2.09551f
C332 enb6 VSS 4.85508f
C333 pm5 VSS 2.01681f
C334 enb5 VSS 5.01876f
C335 pm4 VSS 1.93504f
C336 enb4 VSS 5.36704f
C337 pm3 VSS 1.82905f
C338 enb3 VSS 12.6679f
C339 pm2 VSS 1.83222f
C340 enb2 VSS 4.7844f
C341 pm1 VSS 1.76116f
C342 enb1 VSS 5.14124f
C343 pm0 VSS 1.68096f
C344 enb0 VSS 6.16037f
.ends
