* NGSPICE file created from pt_bias_root.ext - technology: gf180mcuD

.subckt pt_bias_root VSS ROOT_REF EN_RF EN_CONV EN_PLL EN_WIRE EN_DEBUG TRK_RF TRK_CONV
+ TRK_PLL TRK_WIRE TRK_DEBUG
X0 VSS ROOT_REF m_debug VSS nfet_03v3 ad=1.76p pd=8.88u as=1.04p ps=4.52u w=4u l=4u
X1 VSS ROOT_REF m_pll VSS nfet_03v3 ad=1.76p pd=8.88u as=1.04p ps=4.52u w=4u l=4u
X2 VSS ROOT_REF m_wire VSS nfet_03v3 ad=1.76p pd=8.88u as=1.04p ps=4.52u w=4u l=4u
X3 TRK_WIRE EN_WIRE m_wire VSS nfet_03v3 ad=1.76p pd=8.88u as=1.76p ps=8.88u w=4u l=0.5u
X4 VSS ROOT_REF m_conv VSS nfet_03v3 ad=1.76p pd=8.88u as=1.04p ps=4.52u w=4u l=4u
X5 VSS ROOT_REF m_rf VSS nfet_03v3 ad=1.76p pd=8.88u as=1.04p ps=4.52u w=4u l=4u
X6 m_wire ROOT_REF VSS VSS nfet_03v3 ad=1.04p pd=4.52u as=1.76p ps=8.88u w=4u l=4u
X7 VSS ROOT_REF ROOT_REF VSS nfet_03v3 ad=1.76p pd=8.88u as=1.04p ps=4.52u w=4u l=4u
X8 m_conv ROOT_REF VSS VSS nfet_03v3 ad=1.04p pd=4.52u as=1.76p ps=8.88u w=4u l=4u
X9 m_debug ROOT_REF VSS VSS nfet_03v3 ad=1.04p pd=4.52u as=1.76p ps=8.88u w=4u l=4u
X10 m_pll ROOT_REF VSS VSS nfet_03v3 ad=1.04p pd=4.52u as=1.76p ps=8.88u w=4u l=4u
X11 TRK_DEBUG EN_DEBUG m_debug VSS nfet_03v3 ad=1.76p pd=8.88u as=1.76p ps=8.88u w=4u l=0.5u
X12 m_rf ROOT_REF VSS VSS nfet_03v3 ad=1.04p pd=4.52u as=1.76p ps=8.88u w=4u l=4u
X13 TRK_RF EN_RF m_rf VSS nfet_03v3 ad=1.76p pd=8.88u as=1.76p ps=8.88u w=4u l=0.5u
X14 TRK_PLL EN_PLL m_pll VSS nfet_03v3 ad=1.76p pd=8.88u as=1.76p ps=8.88u w=4u l=0.5u
X15 TRK_CONV EN_CONV m_conv VSS nfet_03v3 ad=1.76p pd=8.88u as=1.76p ps=8.88u w=4u l=0.5u
X16 ROOT_REF ROOT_REF VSS VSS nfet_03v3 ad=1.04p pd=4.52u as=1.76p ps=8.88u w=4u l=4u
C0 EN_WIRE EN_RF 3.44615f
C1 TRK_DEBUG TRK_WIRE 3.85726f
C2 TRK_WIRE EN_DEBUG 0.09106f
C3 m_rf TRK_CONV 0.09585f
C4 TRK_WIRE TRK_RF 3.02715f
C5 EN_WIRE TRK_PLL 0.07868f
C6 EN_WIRE m_pll 0.1031f
C7 EN_WIRE TRK_WIRE 0.8188f
C8 m_wire ROOT_REF 1.88863f
C9 m_rf EN_RF 0.1556f
C10 TRK_CONV EN_RF 0.02667f
C11 TRK_DEBUG EN_CONV 0.04941f
C12 EN_DEBUG EN_CONV 5.1035f
C13 TRK_RF EN_CONV 0.09363f
C14 TRK_DEBUG m_conv 0.09648f
C15 EN_DEBUG m_conv 0.09154f
C16 TRK_DEBUG EN_PLL 0.03933f
C17 m_rf TRK_PLL 0.09585f
C18 EN_PLL EN_DEBUG 6.89255f
C19 TRK_CONV TRK_PLL 3.06027f
C20 EN_PLL TRK_RF 0.07392f
C21 TRK_DEBUG ROOT_REF 2.70206f
C22 ROOT_REF EN_DEBUG 0.83455f
C23 TRK_RF ROOT_REF 0.13481f
C24 m_rf TRK_WIRE 0.09648f
C25 TRK_CONV TRK_WIRE 0.03088f
C26 EN_WIRE EN_CONV 0.04114f
C27 EN_WIRE m_conv 0.1031f
C28 EN_WIRE EN_PLL 4.24871f
C29 EN_WIRE ROOT_REF 8.9782f
C30 TRK_DEBUG m_wire 0.12458f
C31 m_wire EN_DEBUG 0.1404f
C32 TRK_PLL EN_RF 0.02629f
C33 TRK_WIRE EN_RF 0.0262f
C34 EN_WIRE m_wire 0.17221f
C35 m_pll TRK_PLL 0.56761f
C36 m_rf EN_CONV 0.12579f
C37 TRK_CONV EN_CONV 0.56881f
C38 TRK_CONV m_conv 0.52732f
C39 TRK_PLL TRK_WIRE 5.28908f
C40 m_rf EN_PLL 0.09134f
C41 m_pll TRK_WIRE 0.10851f
C42 TRK_CONV EN_PLL 0.07877f
C43 TRK_DEBUG EN_DEBUG 0.75553f
C44 m_rf ROOT_REF 1.8766f
C45 TRK_DEBUG TRK_RF 0.04854f
C46 TRK_CONV ROOT_REF 4.94753f
C47 TRK_RF EN_DEBUG 2.15431f
C48 EN_WIRE TRK_DEBUG 0.03965f
C49 EN_WIRE EN_DEBUG 2.82044f
C50 EN_WIRE TRK_RF 0.26808f
C51 m_debug ROOT_REF 1.84418f
C52 EN_RF EN_CONV 1.99554f
C53 EN_PLL EN_RF 3.59963f
C54 ROOT_REF EN_RF 2.6933f
C55 TRK_PLL EN_CONV 0.03634f
C56 TRK_PLL m_conv 0.10851f
C57 EN_PLL TRK_PLL 0.68265f
C58 m_pll EN_PLL 0.16782f
C59 TRK_PLL ROOT_REF 0.08324f
C60 TRK_WIRE EN_CONV 0.03627f
C61 m_pll ROOT_REF 1.88868f
C62 TRK_WIRE m_conv 0.10851f
C63 EN_PLL TRK_WIRE 0.02618f
C64 m_rf TRK_DEBUG 0.09585f
C65 TRK_CONV TRK_DEBUG 4.68049f
C66 m_rf EN_DEBUG 0.09154f
C67 TRK_WIRE ROOT_REF 0.08184f
C68 TRK_CONV EN_DEBUG 0.07282f
C69 m_rf TRK_RF 0.56972f
C70 TRK_CONV TRK_RF 3.02545f
C71 m_rf EN_WIRE 0.09107f
C72 EN_WIRE TRK_CONV 0.07868f
C73 TRK_DEBUG m_debug 0.57705f
C74 m_debug EN_DEBUG 0.20824f
C75 m_wire TRK_WIRE 0.60055f
C76 TRK_DEBUG EN_RF 0.03943f
C77 EN_DEBUG EN_RF 0.03476f
C78 TRK_RF EN_RF 0.74985f
C79 EN_CONV m_conv 0.19024f
C80 EN_PLL EN_CONV 2.03683f
C81 ROOT_REF EN_CONV 0.44172f
C82 EN_PLL m_conv 0.10337f
C83 TRK_DEBUG TRK_PLL 6.47f
C84 ROOT_REF m_conv 1.8767f
C85 TRK_PLL EN_DEBUG 0.08272f
C86 m_pll TRK_DEBUG 0.10788f
C87 EN_PLL ROOT_REF 0.21946f
C88 m_pll EN_DEBUG 0.1237f
C89 TRK_PLL TRK_RF 3.1879f
C90 TRK_DEBUG VSS 4.2695f
C91 EN_DEBUG VSS 5.0667f
C92 TRK_WIRE VSS 11.1777f
C93 EN_WIRE VSS 3.0892f
C94 TRK_PLL VSS 2.37818f
C95 EN_PLL VSS 2.55565f
C96 TRK_CONV VSS 1.93126f
C97 EN_CONV VSS 3.83392f
C98 TRK_RF VSS 1.96812f
C99 EN_RF VSS 1.98705f
C100 ROOT_REF VSS 36.5899f
C101 m_debug VSS 3.29453f
C102 m_wire VSS 3.41613f
C103 m_pll VSS 3.30371f
C104 m_conv VSS 3.33147f
C105 m_rf VSS 3.35518f
.ends
