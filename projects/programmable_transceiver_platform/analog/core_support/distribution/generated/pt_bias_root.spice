* pt_bias_root: generated by analog/rf_tx/circuits.py
* Master-side trunk splitter: ROOT_REF receives 10 uA (biasgen idac2, or ATB force);
* one 1:1 NMOS leg per island trunk, switched by EN_<island> (default off).
.subckt pt_bias_root VSS ROOT_REF EN_RF EN_CONV EN_PLL EN_WIRE EN_DEBUG TRK_RF TRK_CONV TRK_PLL TRK_WIRE TRK_DEBUG
XMREF_f0 ROOT_REF ROOT_REF VSS VSS nfet_03v3 w=4u l=4u ad=1.76p as=1.76p pd=8.88u ps=8.88u
XMREF_f1 ROOT_REF ROOT_REF VSS VSS nfet_03v3 w=4u l=4u ad=1.76p as=1.76p pd=8.88u ps=8.88u
XM_RF_f0 m_rf ROOT_REF VSS VSS nfet_03v3 w=4u l=4u ad=1.76p as=1.76p pd=8.88u ps=8.88u
XM_RF_f1 m_rf ROOT_REF VSS VSS nfet_03v3 w=4u l=4u ad=1.76p as=1.76p pd=8.88u ps=8.88u
XSW_RF TRK_RF EN_RF m_rf VSS nfet_03v3 w=4u l=0.5u ad=1.76p as=1.76p pd=8.88u ps=8.88u
XM_CONV_f0 m_conv ROOT_REF VSS VSS nfet_03v3 w=4u l=4u ad=1.76p as=1.76p pd=8.88u ps=8.88u
XM_CONV_f1 m_conv ROOT_REF VSS VSS nfet_03v3 w=4u l=4u ad=1.76p as=1.76p pd=8.88u ps=8.88u
XSW_CONV TRK_CONV EN_CONV m_conv VSS nfet_03v3 w=4u l=0.5u ad=1.76p as=1.76p pd=8.88u ps=8.88u
XM_PLL_f0 m_pll ROOT_REF VSS VSS nfet_03v3 w=4u l=4u ad=1.76p as=1.76p pd=8.88u ps=8.88u
XM_PLL_f1 m_pll ROOT_REF VSS VSS nfet_03v3 w=4u l=4u ad=1.76p as=1.76p pd=8.88u ps=8.88u
XSW_PLL TRK_PLL EN_PLL m_pll VSS nfet_03v3 w=4u l=0.5u ad=1.76p as=1.76p pd=8.88u ps=8.88u
XM_WIRE_f0 m_wire ROOT_REF VSS VSS nfet_03v3 w=4u l=4u ad=1.76p as=1.76p pd=8.88u ps=8.88u
XM_WIRE_f1 m_wire ROOT_REF VSS VSS nfet_03v3 w=4u l=4u ad=1.76p as=1.76p pd=8.88u ps=8.88u
XSW_WIRE TRK_WIRE EN_WIRE m_wire VSS nfet_03v3 w=4u l=0.5u ad=1.76p as=1.76p pd=8.88u ps=8.88u
XM_DEBUG_f0 m_debug ROOT_REF VSS VSS nfet_03v3 w=4u l=4u ad=1.76p as=1.76p pd=8.88u ps=8.88u
XM_DEBUG_f1 m_debug ROOT_REF VSS VSS nfet_03v3 w=4u l=4u ad=1.76p as=1.76p pd=8.88u ps=8.88u
XSW_DEBUG TRK_DEBUG EN_DEBUG m_debug VSS nfet_03v3 w=4u l=0.5u ad=1.76p as=1.76p pd=8.88u ps=8.88u
.ends pt_bias_root
