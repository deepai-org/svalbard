* pt_bias_tap2: generated by analog/rf_tx/circuits.py
* 2 more switched 10 uA source outputs on an island trunk; no diode (the diode is in the island bank).
.subckt pt_bias_tap2 VDD VSS TRK EN0 EN1 OUT0 OUT1
XI0_N enb0 EN0 VSS VSS nfet_03v3 w=4u l=0.28u ad=1.76p as=1.76p pd=8.88u ps=8.88u
XI0_P enb0 EN0 VDD VDD pfet_03v3 w=8u l=0.28u ad=3.52p as=3.52p pd=16.88u ps=16.88u
XPM0_f0 pm0 TRK VDD VDD pfet_03v3 w=5u l=4u ad=2.2p as=2.2p pd=10.88u ps=10.88u
XPM0_f1 pm0 TRK VDD VDD pfet_03v3 w=5u l=4u ad=2.2p as=2.2p pd=10.88u ps=10.88u
XPS0 OUT0 enb0 pm0 VDD pfet_03v3 w=8u l=0.5u ad=3.52p as=3.52p pd=16.88u ps=16.88u
XI1_N enb1 EN1 VSS VSS nfet_03v3 w=4u l=0.28u ad=1.76p as=1.76p pd=8.88u ps=8.88u
XI1_P enb1 EN1 VDD VDD pfet_03v3 w=8u l=0.28u ad=3.52p as=3.52p pd=16.88u ps=16.88u
XPM1_f0 pm1 TRK VDD VDD pfet_03v3 w=5u l=4u ad=2.2p as=2.2p pd=10.88u ps=10.88u
XPM1_f1 pm1 TRK VDD VDD pfet_03v3 w=5u l=4u ad=2.2p as=2.2p pd=10.88u ps=10.88u
XPS1 OUT1 enb1 pm1 VDD pfet_03v3 w=8u l=0.5u ad=3.52p as=3.52p pd=16.88u ps=16.88u
.ends pt_bias_tap2
