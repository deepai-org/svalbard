* pt_bias_vref: generated by analog/rf_tx/circuits.py
* Passive master references: VREF0 = 5/6 VBG, VCM = VDD/2 (always on, core VDD).
.subckt pt_bias_vref VDD VSS VBG VREF0 VCM
XRV_T VBG VREF0 VSS ppolyf_u_1k r_width=1u r_length=40u
XRV_B0 VREF0 v1 VSS ppolyf_u_1k r_width=1u r_length=40u
XRV_B1 v1 v2 VSS ppolyf_u_1k r_width=1u r_length=40u
XRV_B2 v2 v3 VSS ppolyf_u_1k r_width=1u r_length=40u
XRV_B3 v3 v4 VSS ppolyf_u_1k r_width=1u r_length=40u
XRV_B4 v4 VSS VSS ppolyf_u_1k r_width=1u r_length=40u
XRC_0 VDD c1 VSS ppolyf_u_1k r_width=1u r_length=40u
XRC_1 c1 VCM VSS ppolyf_u_1k r_width=1u r_length=40u
XRC_2 VCM c2 VSS ppolyf_u_1k r_width=1u r_length=40u
XRC_3 c2 VSS VSS ppolyf_u_1k r_width=1u r_length=40u
.ends pt_bias_vref
