* pt_refvcm: generated by analog/rf_tx/circuits.py
* Refpad common-mode source: VCM = VDD/2 when EN, 0 V when off; separate from the ADC VCM_MASTER.
.subckt pt_refvcm VDD VSS EN VCM
XIE_N enb EN VSS VSS nfet_03v3 w=4u l=0.28u ad=1.76p as=1.76p pd=8.88u ps=8.88u
XIE_P enb EN VDD VDD pfet_03v3 w=8u l=0.28u ad=3.52p as=3.52p pd=16.88u ps=16.88u
XPH_f0 top enb VDD VDD pfet_03v3 w=10u l=0.5u ad=4.4p as=4.4p pd=20.88u ps=20.88u
XPH_f1 top enb VDD VDD pfet_03v3 w=10u l=0.5u ad=4.4p as=4.4p pd=20.88u ps=20.88u
XRC_0 top t1 VSS ppolyf_u_1k r_width=1u r_length=40u
XRC_1 t1 VCM VSS ppolyf_u_1k r_width=1u r_length=40u
XRC_2 VCM b1 VSS ppolyf_u_1k r_width=1u r_length=40u
XRC_3 b1 VSS VSS ppolyf_u_1k r_width=1u r_length=40u
XCD0 VSS VCM VSS VSS nfet_03v3 w=20u l=10u ad=8.8p as=8.8p pd=40.88u ps=40.88u
XCD1 VSS VCM VSS VSS nfet_03v3 w=20u l=10u ad=8.8p as=8.8p pd=40.88u ps=40.88u
XCD2 VSS VCM VSS VSS nfet_03v3 w=20u l=10u ad=8.8p as=8.8p pd=40.88u ps=40.88u
XCD3 VSS VCM VSS VSS nfet_03v3 w=20u l=10u ad=8.8p as=8.8p pd=40.88u ps=40.88u
.ends pt_refvcm
