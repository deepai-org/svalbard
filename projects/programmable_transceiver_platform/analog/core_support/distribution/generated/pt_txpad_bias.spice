* pt_txpad_bias: generated by analog/rf_tx/circuits.py
* TX-pad termination buffer REF/BIAS dividers (gated) and detect-source PMOS bias (gated).
.subckt pt_txpad_bias VDD VSS EN BUF_REF BUF_BIAS EN_DET IBIAS_DET DETECT_PBIAS
XIE_N enb EN VSS VSS nfet_03v3 w=4u l=0.28u ad=1.76p as=1.76p pd=8.88u ps=8.88u
XIE_P enb EN VDD VDD pfet_03v3 w=8u l=0.28u ad=3.52p as=3.52p pd=16.88u ps=16.88u
XPHR_f0 rtop enb VDD VDD pfet_03v3 w=20u l=0.5u ad=8.8p as=8.8p pd=40.88u ps=40.88u
XPHR_f1 rtop enb VDD VDD pfet_03v3 w=20u l=0.5u ad=8.8p as=8.8p pd=40.88u ps=40.88u
XPHR_f2 rtop enb VDD VDD pfet_03v3 w=20u l=0.5u ad=8.8p as=8.8p pd=40.88u ps=40.88u
XPHR_f3 rtop enb VDD VDD pfet_03v3 w=20u l=0.5u ad=8.8p as=8.8p pd=40.88u ps=40.88u
XRR_T rtop BUF_REF VSS ppolyf_u_1k r_width=2u r_length=20u
XRR_B BUF_REF VSS VSS ppolyf_u_1k r_width=2u r_length=20u
XPHB_f0 btop enb VDD VDD pfet_03v3 w=10u l=0.5u ad=4.4p as=4.4p pd=20.88u ps=20.88u
XPHB_f1 btop enb VDD VDD pfet_03v3 w=10u l=0.5u ad=4.4p as=4.4p pd=20.88u ps=20.88u
XRB_T0 btop bt0 VSS ppolyf_u_1k r_width=2u r_length=20u
XRB_T1 bt0 bt1 VSS ppolyf_u_1k r_width=2u r_length=20u
XRB_T2 bt1 bt2 VSS ppolyf_u_1k r_width=2u r_length=20u
XRB_T3 bt2 bt3 VSS ppolyf_u_1k r_width=2u r_length=20u
XRB_T4 bt3 bt4 VSS ppolyf_u_1k r_width=2u r_length=20u
XRB_T5 bt4 bt5 VSS ppolyf_u_1k r_width=2u r_length=20u
XRB_T6 bt5 bt6 VSS ppolyf_u_1k r_width=2u r_length=20u
XRB_T7 bt6 BUF_BIAS VSS ppolyf_u_1k r_width=2u r_length=20u
XRB_B0 BUF_BIAS bb0 VSS ppolyf_u_1k r_width=2u r_length=20u
XRB_B1 bb0 bb1 VSS ppolyf_u_1k r_width=2u r_length=20u
XRB_B2 bb1 VSS VSS ppolyf_u_1k r_width=2u r_length=20u
XID_N endb EN_DET VSS VSS nfet_03v3 w=4u l=0.28u ad=1.76p as=1.76p pd=8.88u ps=8.88u
XID_P endb EN_DET VDD VDD pfet_03v3 w=8u l=0.28u ad=3.52p as=3.52p pd=16.88u ps=16.88u
XSWD IBIAS_DET EN_DET nd VSS nfet_03v3 w=4u l=0.5u ad=1.76p as=1.76p pd=8.88u ps=8.88u
XPDN nd endb VSS VSS nfet_03v3 w=2u l=0.28u ad=0.88p as=0.88p pd=4.88u ps=4.88u
XMD_f0 nd nd VSS VSS nfet_03v3 w=4u l=4u ad=1.76p as=1.76p pd=8.88u ps=8.88u
XMD_f1 nd nd VSS VSS nfet_03v3 w=4u l=4u ad=1.76p as=1.76p pd=8.88u ps=8.88u
XMM0_f0 DETECT_PBIAS nd VSS VSS nfet_03v3 w=4u l=4u ad=1.76p as=1.76p pd=8.88u ps=8.88u
XMM0_f1 DETECT_PBIAS nd VSS VSS nfet_03v3 w=4u l=4u ad=1.76p as=1.76p pd=8.88u ps=8.88u
XMM1_f0 DETECT_PBIAS nd VSS VSS nfet_03v3 w=4u l=4u ad=1.76p as=1.76p pd=8.88u ps=8.88u
XMM1_f1 DETECT_PBIAS nd VSS VSS nfet_03v3 w=4u l=4u ad=1.76p as=1.76p pd=8.88u ps=8.88u
XMM2_f0 DETECT_PBIAS nd VSS VSS nfet_03v3 w=4u l=4u ad=1.76p as=1.76p pd=8.88u ps=8.88u
XMM2_f1 DETECT_PBIAS nd VSS VSS nfet_03v3 w=4u l=4u ad=1.76p as=1.76p pd=8.88u ps=8.88u
XMM3_f0 DETECT_PBIAS nd VSS VSS nfet_03v3 w=4u l=4u ad=1.76p as=1.76p pd=8.88u ps=8.88u
XMM3_f1 DETECT_PBIAS nd VSS VSS nfet_03v3 w=4u l=4u ad=1.76p as=1.76p pd=8.88u ps=8.88u
XMM4_f0 DETECT_PBIAS nd VSS VSS nfet_03v3 w=4u l=4u ad=1.76p as=1.76p pd=8.88u ps=8.88u
XMM4_f1 DETECT_PBIAS nd VSS VSS nfet_03v3 w=4u l=4u ad=1.76p as=1.76p pd=8.88u ps=8.88u
XPD DETECT_PBIAS DETECT_PBIAS VDD VDD pfet_03v3 w=4u l=2u ad=1.76p as=1.76p pd=8.88u ps=8.88u
XPUP DETECT_PBIAS EN_DET VDD VDD pfet_03v3 w=2u l=0.28u ad=0.88p as=0.88p pd=4.88u ps=4.88u
.ends pt_txpad_bias
