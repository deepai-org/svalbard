* Static CMOS decoder candidate; no retiming or hazard suppression.
.subckt pt_dac_dec_inv A Y VDD VSS
XP Y A VDD VDD pfet_03v3 w=2u l=.28u
XN Y A VSS VSS nfet_03v3 w=1u l=.28u
.ends
.subckt pt_dac_dec_and A B Y VDD VSS
XP0 N A VDD VDD pfet_03v3 w=2u l=.28u
XP1 N B VDD VDD pfet_03v3 w=2u l=.28u
XN0 N A S VSS nfet_03v3 w=2u l=.28u
XN1 S B VSS VSS nfet_03v3 w=2u l=.28u
XI N Y VDD VSS pt_dac_dec_inv
.ends
.subckt pt_dac_dec_or A B Y VDD VSS
XP0 S A VDD VDD pfet_03v3 w=4u l=.28u
XP1 N B S VDD pfet_03v3 w=4u l=.28u
XN0 N A VSS VSS nfet_03v3 w=1u l=.28u
XN1 N B VSS VSS nfet_03v3 w=1u l=.28u
XI N Y VDD VSS pt_dac_dec_inv
.ends
.subckt pt_dac_thermometer4 D0 D1 D2 D3 T1 T2 T3 T4 T5 T6 T7 T8 T9 T10 T11 T12 T13 T14 T15 VDD VSS
XG2_1 D1 D0 G2_1 VDD VSS pt_dac_dec_or
XG3_1 D2 G2_1 G3_1 VDD VSS pt_dac_dec_or
XG4_1 D3 G3_1 G4_1 VDD VSS pt_dac_dec_or
XG3_2 D2 D1 G3_2 VDD VSS pt_dac_dec_or
XG4_2 D3 G3_2 G4_2 VDD VSS pt_dac_dec_or
XG2_3 D1 D0 G2_3 VDD VSS pt_dac_dec_and
XG3_3 D2 G2_3 G3_3 VDD VSS pt_dac_dec_or
XG4_3 D3 G3_3 G4_3 VDD VSS pt_dac_dec_or
XG4_4 D3 D2 G4_4 VDD VSS pt_dac_dec_or
XG3_5 D2 G2_1 G3_5 VDD VSS pt_dac_dec_and
XG4_5 D3 G3_5 G4_5 VDD VSS pt_dac_dec_or
XG3_6 D2 D1 G3_6 VDD VSS pt_dac_dec_and
XG4_6 D3 G3_6 G4_6 VDD VSS pt_dac_dec_or
XG3_7 D2 G2_3 G3_7 VDD VSS pt_dac_dec_and
XG4_7 D3 G3_7 G4_7 VDD VSS pt_dac_dec_or
XG4_9 D3 G3_1 G4_9 VDD VSS pt_dac_dec_and
XG4_10 D3 G3_2 G4_10 VDD VSS pt_dac_dec_and
XG4_11 D3 G3_3 G4_11 VDD VSS pt_dac_dec_and
XG4_12 D3 D2 G4_12 VDD VSS pt_dac_dec_and
XG4_13 D3 G3_5 G4_13 VDD VSS pt_dac_dec_and
XG4_14 D3 G3_6 G4_14 VDD VSS pt_dac_dec_and
XG4_15 D3 G3_7 G4_15 VDD VSS pt_dac_dec_and
XB1 G4_1 N1 VDD VSS pt_dac_dec_inv
XO1 N1 T1 VDD VSS pt_dac_dec_inv
XB2 G4_2 N2 VDD VSS pt_dac_dec_inv
XO2 N2 T2 VDD VSS pt_dac_dec_inv
XB3 G4_3 N3 VDD VSS pt_dac_dec_inv
XO3 N3 T3 VDD VSS pt_dac_dec_inv
XB4 G4_4 N4 VDD VSS pt_dac_dec_inv
XO4 N4 T4 VDD VSS pt_dac_dec_inv
XB5 G4_5 N5 VDD VSS pt_dac_dec_inv
XO5 N5 T5 VDD VSS pt_dac_dec_inv
XB6 G4_6 N6 VDD VSS pt_dac_dec_inv
XO6 N6 T6 VDD VSS pt_dac_dec_inv
XB7 G4_7 N7 VDD VSS pt_dac_dec_inv
XO7 N7 T7 VDD VSS pt_dac_dec_inv
XB8 D3 N8 VDD VSS pt_dac_dec_inv
XO8 N8 T8 VDD VSS pt_dac_dec_inv
XB9 G4_9 N9 VDD VSS pt_dac_dec_inv
XO9 N9 T9 VDD VSS pt_dac_dec_inv
XB10 G4_10 N10 VDD VSS pt_dac_dec_inv
XO10 N10 T10 VDD VSS pt_dac_dec_inv
XB11 G4_11 N11 VDD VSS pt_dac_dec_inv
XO11 N11 T11 VDD VSS pt_dac_dec_inv
XB12 G4_12 N12 VDD VSS pt_dac_dec_inv
XO12 N12 T12 VDD VSS pt_dac_dec_inv
XB13 G4_13 N13 VDD VSS pt_dac_dec_inv
XO13 N13 T13 VDD VSS pt_dac_dec_inv
XB14 G4_14 N14 VDD VSS pt_dac_dec_inv
XO14 N14 T14 VDD VSS pt_dac_dec_inv
XB15 G4_15 N15 VDD VSS pt_dac_dec_inv
XO15 N15 T15 VDD VSS pt_dac_dec_inv
.ends
