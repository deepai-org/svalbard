* pt_decap_tile reference (schematic intent)
.subckt pt_decap_tile VSS VDD
XMPCAP1 VDD GB VDD VDD pfet_03v3 w=27.5u l=6u
XMPCAP2 VDD GB VDD VDD pfet_03v3 w=27.5u l=6u
XMPCAP3 VDD GB VDD VDD pfet_03v3 w=27.5u l=6u
XMPCAP4 VDD GB VDD VDD pfet_03v3 w=27.5u l=6u
XMPCAP5 VDD GB VDD VDD pfet_03v3 w=27.5u l=6u
XMPT G GB VDD VDD pfet_03v3 w=1u l=0.5u
XMNT1 GB G VSS VSS nfet_03v3 w=4u l=0.5u
XMNT2 GB G VSS VSS nfet_03v3 w=4u l=0.5u
XMNT3 GB G VSS VSS nfet_03v3 w=4u l=0.5u
XMNT4 GB G VSS VSS nfet_03v3 w=4u l=0.5u
XMNT5 GB G VSS VSS nfet_03v3 w=4u l=0.5u
XMNT6 GB G VSS VSS nfet_03v3 w=4u l=0.5u
XMNT7 GB G VSS VSS nfet_03v3 w=4u l=0.5u
XMNT8 GB G VSS VSS nfet_03v3 w=4u l=0.5u
XMNT9 GB G VSS VSS nfet_03v3 w=4u l=0.5u
XMNT10 GB G VSS VSS nfet_03v3 w=4u l=0.5u
XMNT11 GB G VSS VSS nfet_03v3 w=4u l=0.5u
XMNT12 GB G VSS VSS nfet_03v3 w=4u l=0.5u
XMNT13 GB G VSS VSS nfet_03v3 w=4u l=0.5u
XMNT14 GB G VSS VSS nfet_03v3 w=4u l=0.5u
XMNT15 GB G VSS VSS nfet_03v3 w=4u l=0.5u
XMNT16 GB G VSS VSS nfet_03v3 w=4u l=0.5u
.ends
