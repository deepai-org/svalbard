* NGSPICE file created from atb_grp_flat.ext - technology: gf180mcuD

.subckt atb_grp_flat NODE BUS SEL VDD VSS
X0 NNO SD SHON VDD pfet_03v3 ad=0.88p pd=4.88u as=0.88p ps=4.88u w=2u l=0.28u
D0 VSS SEL diode_nd2ps_03v3 pj=14p area=12.25p
X1 VSS SEL SHON VSS nfet_03v3 ad=0.44p pd=2.88u as=0.44p ps=2.88u w=1u l=0.28u
X2 VDD SD TGONB VDD pfet_03v3 ad=0.44p pd=2.88u as=0.44p ps=2.88u w=1u l=0.28u
X3 VSS TGONB TGON VSS nfet_03v3 ad=0.44p pd=2.88u as=0.44p ps=2.88u w=1u l=0.28u
X4 MID TGON NODE VSS nfet_03v3 ad=3.52p pd=16.88u as=3.52p ps=16.88u w=8u l=0.28u
X5 VSS SD NNA VSS nfet_03v3 ad=0.44p pd=2.88u as=0.44p ps=2.88u w=1u l=0.28u
X6 VDD SEL NNO VDD pfet_03v3 ad=0.88p pd=4.88u as=0.88p ps=4.88u w=2u l=0.28u
X7 VDD SEL TGONB VDD pfet_03v3 ad=0.44p pd=2.88u as=0.44p ps=2.88u w=1u l=0.28u
X8 VDD SEL SA VDD pfet_03v3 ad=0.3696p pd=2.56u as=0.3696p ps=2.56u w=0.84u l=2u
X9 VDD SA SD VDD pfet_03v3 ad=0.3696p pd=2.56u as=0.3696p ps=2.56u w=0.84u l=2u
X10 VDD TGONB TGON VDD pfet_03v3 ad=0.88p pd=4.88u as=0.88p ps=4.88u w=2u l=0.28u
X11 BUS TGON MID VSS nfet_03v3 ad=3.52p pd=16.88u as=3.52p ps=16.88u w=8u l=0.28u
X12 VSS SHON MID VSS nfet_03v3 ad=0.88p pd=4.88u as=0.88p ps=4.88u w=2u l=0.28u
X13 NNA SEL TGONB VSS nfet_03v3 ad=0.44p pd=2.88u as=0.44p ps=2.88u w=1u l=0.28u
X14 VSS VDD SEL VSS nfet_03v3 ad=0.1848p pd=1.72u as=0.1848p ps=1.72u w=0.42u l=20u
X15 BUS TGONB MID VDD pfet_03v3 ad=7.04p pd=32.88u as=7.04p ps=32.88u w=16u l=0.28u
X16 MID TGONB NODE VDD pfet_03v3 ad=7.04p pd=32.88u as=7.04p ps=32.88u w=16u l=0.28u
X17 VSS SD SHON VSS nfet_03v3 ad=0.44p pd=2.88u as=0.44p ps=2.88u w=1u l=0.28u
X18 VSS SEL SA VSS nfet_03v3 ad=0.1848p pd=1.72u as=0.1848p ps=1.72u w=0.42u l=2u
X19 VSS SA SD VSS nfet_03v3 ad=0.1848p pd=1.72u as=0.1848p ps=1.72u w=0.42u l=2u
C0 TGON SA 0.46679f
C1 SEL SD 4.21946f
C2 VDD NODE 0.9065f
C3 BUS SD 0.73788f
C4 VDD NNO 2.10373f
C5 SHON SA 0.16199f
C6 VDD TGONB 6.32416f
C7 SEL BUS 0.66123f
C8 SD TGON 2.849f
C9 SEL TGON 0.77971f
C10 SHON SD 2.81021f
C11 NODE TGONB 1.52966f
C12 BUS TGON 0.68712f
C13 NNO TGONB 0.56238f
C14 SEL SHON 1.09836f
C15 MID SA 4.02195f
C16 SHON BUS 7.69115f
C17 SHON TGON 1.13806f
C18 NNA VDD 0.01294f
C19 MID SD 0.54864f
C20 SEL MID 8.59846f
C21 MID BUS 4.4327f
C22 NNA TGONB 0.82026f
C23 VDD SA 9.53195f
C24 MID TGON 10.1247f
C25 SHON MID 1.25101f
C26 SD VDD 4.80395f
C27 SA NNO 0.18456f
C28 SA TGONB 0.41663f
C29 SEL VDD 15.6829f
C30 BUS VDD 7.22687f
C31 SD NNO 0.29131f
C32 TGON VDD 2.45974f
C33 SD TGONB 6.52548f
C34 SEL NNO 1.45228f
C35 SEL TGONB 2.59045f
C36 BUS NNO 0.24147f
C37 SHON VDD 0.91342f
C38 BUS TGONB 1.07606f
C39 TGON NODE 0.121f
C40 TGON NNO 0.59412f
C41 TGON TGONB 2.41332f
C42 SHON NNO 1.27285f
C43 SHON TGONB 3.44024f
C44 MID VDD 3.62271f
C45 SD NNA 1.40471f
C46 SEL NNA 0.07593f
C47 MID NODE 4.0072f
C48 BUS NNA 0.2983f
C49 MID NNO 0.24849f
C50 MID TGONB 5.13095f
C51 NNA TGON 0.03087f
C52 SD SA 8.37889f
C53 SEL SA 6.87551f
C54 BUS SA 0.38342f
C55 BUS VSS 11.828f
C56 SEL VSS 13.6563f
C57 NODE VSS 1.5116f
C58 VDD VSS 0.16651p
C59 NNA VSS 1.7205f ; **FLOATING
C60 SHON VSS 5.56936f ; **FLOATING
C61 NNO VSS 0.81215f ; **FLOATING
C62 SA VSS 6.62856f ; **FLOATING
C63 TGON VSS 15.8139f ; **FLOATING
C64 SD VSS 7.39772f ; **FLOATING
C65 MID VSS 8.33813f ; **FLOATING
C66 TGONB VSS 7.34301f ; **FLOATING
.ends
