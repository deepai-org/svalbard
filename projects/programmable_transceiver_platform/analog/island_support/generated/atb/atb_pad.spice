.subckt atb_pad PAD BUS SEL VDD VSS
XMSPD SEL VDD VSS VSS nfet_03v3 w=0.42u l=20u
XMD1P SA SEL VDD VDD pfet_03v3 w=0.84u l=2u
XMD1N SA SEL VSS VSS nfet_03v3 w=0.42u l=2u
XMD2P SD SA VDD VDD pfet_03v3 w=0.84u l=2u
XMD2N SD SA VSS VSS nfet_03v3 w=0.42u l=2u
XMNAP1 TGONB SEL VDD VDD pfet_03v3 w=1u l=0.28u
XMNAP2 TGONB SD VDD VDD pfet_03v3 w=1u l=0.28u
XMNAN1 TGONB SEL NNA VSS nfet_03v3 w=1u l=0.28u
XMNAN2 NNA SD VSS VSS nfet_03v3 w=1u l=0.28u
XMTGP TGON TGONB VDD VDD pfet_03v3 w=2u l=0.28u
XMTGN TGON TGONB VSS VSS nfet_03v3 w=1u l=0.28u
XMNOP1 NNO SEL VDD VDD pfet_03v3 w=2u l=0.28u
XMNOP2 SHON SD NNO VDD pfet_03v3 w=2u l=0.28u
XMNON1 SHON SEL VSS VSS nfet_03v3 w=1u l=0.28u
XMNON2 SHON SD VSS VSS nfet_03v3 w=1u l=0.28u
XMB1 VMAX PAD VDD VMAX pfet_03v3 w=2u l=0.28u
XMB2 VMAX VDD PAD VMAX pfet_03v3 w=2u l=0.28u
XMGPU GP TGON VMAX VMAX pfet_03v3 w=1u l=0.28u
XMGPD GP TGON VSS VSS nfet_03v3 w=1u l=0.28u
XMTN PAD TGON BUS VSS nfet_03v3 w=8u l=0.28u
XMTP PAD GP BUS VMAX pfet_03v3 w=16u l=0.28u
XMSH BUS SHON VSS VSS nfet_03v3 w=2u l=0.28u
DANT0 VSS SEL diode_nd2ps_03v3 area=12.25p pj=14u
.ends atb_pad
