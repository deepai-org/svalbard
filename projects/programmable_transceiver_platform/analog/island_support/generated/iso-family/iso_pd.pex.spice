* PEX produced on Tue Nov 10 06:57:36 AM CET 2026 using /foss/tools/sak/sak-pex.sh with m=2 and s=1
* NGSPICE file created from iso_pd_pex.ext - technology: gf180mcuD

.subckt iso_pd_pex Y ISO VSS
X0 VSS ISO Y VSS nfet_03v3 ad=0.22p pd=1.88u as=0.22p ps=1.88u w=0.5u l=0.28u
C0 Y ISO 0.3473f
C1 Y VSS 1.4004f
.ends
