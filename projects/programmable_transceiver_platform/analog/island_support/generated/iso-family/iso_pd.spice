.subckt iso_pd Y ISO VSS
XMPD Y ISO VSS VSS nfet_03v3 w=0.5u l=0.28u
.ends iso_pd
