.subckt iso_pd2 P N ISO VSS
XMPDP P ISO VSS VSS nfet_03v3 w=0.5u l=0.28u
XMPDN N ISO VSS VSS nfet_03v3 w=0.5u l=0.28u
.ends iso_pd2
