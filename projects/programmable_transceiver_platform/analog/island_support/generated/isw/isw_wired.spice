.subckt isw_wired VDD VSS VISL EN ISO PG
XMENPD EN VDD VSS VSS nfet_03v3 w=0.42u l=20u
XMINVP ENB EN VDD VDD pfet_03v3 w=2u l=0.28u
XMINVN ENB EN VSS VSS nfet_03v3 w=1u l=0.28u
XMP VISL GATE VDD VMAX pfet_03v3 w=10u l=0.28u m=3520
XMB1 VMAX VISL VDD VMAX pfet_03v3 w=10u l=0.28u m=11
XMB2 VMAX VDD VISL VMAX pfet_03v3 w=10u l=0.28u m=11
XMB3 VMAX GD VDD VMAX pfet_03v3 w=4u l=0.28u
XMRD GD VSS GATE VMAX pfet_03v3 w=0.42u l=40u
XMCD VSS GD VSS VSS nfet_03v3 w=10u l=10u m=2
XMPU GATE EN VMAX VMAX pfet_03v3 w=4u l=0.28u
XMSS GATE EN VSS VSS nfet_03v3 w=0.42u l=20u
XMDIS VISL ENB VSS VSS nfet_03v3 w=3.9u l=1u
XMPG1P PGB VISL VDD VDD pfet_03v3 w=4u l=0.28u
XMPG1N PGB VISL VSS VSS nfet_03v3 w=0.42u l=4u
XMPG2P PG PGB VDD VDD pfet_03v3 w=2u l=0.28u
XMPG2N PG PGB VSS VSS nfet_03v3 w=1u l=0.28u
XMISP1 ISO EN VDD VDD pfet_03v3 w=2u l=0.28u
XMISP2 ISO PG VDD VDD pfet_03v3 w=2u l=0.28u
XMISN1 ISO EN NISO VSS nfet_03v3 w=2u l=0.28u
XMISN2 NISO PG VSS VSS nfet_03v3 w=2u l=0.28u
.ends isw_wired
