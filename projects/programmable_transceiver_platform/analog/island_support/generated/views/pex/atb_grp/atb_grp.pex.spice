* PEX produced on Wed Nov 25 12:26:35 AM CET 2026 using /foss/tools/sak/sak-pex.sh with m=2 and s=1
* NGSPICE file created from atb_grp_pex.ext - technology: gf180mcuD

.subckt atb_grp_pex NODE BUS SEL VDD VSS
X0 NNO SD SHON VDD pfet_03v3 ad=0.88p pd=4.88u as=0.88p ps=4.88u w=2u l=0.28u
D0 VSS SEL diode_nd2ps_03v3 pj=14u area=12.25p
X1 VSS SEL SHON VSS nfet_03v3 ad=0.44p pd=2.88u as=0.44p ps=2.88u w=1u l=0.28u
X2 VDD SD TGONB VDD pfet_03v3 ad=0.44p pd=2.88u as=0.44p ps=2.88u w=1u l=0.28u
X3 VSS TGONB TGON VSS nfet_03v3 ad=0.44p pd=2.88u as=0.44p ps=2.88u w=1u l=0.28u
X4 MID TGON NODE VSS nfet_03v3 ad=3.52p pd=16.88u as=3.52p ps=16.88u w=8u l=0.28u
X5 VSS SD NNA VSS nfet_03v3 ad=0.44p pd=2.88u as=0.44p ps=2.88u w=1u l=0.28u
X6 VDD SEL NNO VDD pfet_03v3 ad=0.88p pd=4.88u as=0.88p ps=4.88u w=2u l=0.28u
X7 VDD SEL TGONB VDD pfet_03v3 ad=0.44p pd=2.88u as=0.44p ps=2.88u w=1u l=0.28u
X8 VDD SEL SA VDD pfet_03v3 ad=0.3696p pd=2.56u as=0.3696p ps=2.56u w=0.84u l=2u
X9 VDD SA SD VDD pfet_03v3 ad=0.3696p pd=2.56u as=0.3696p ps=2.56u w=0.84u l=2u
X10 VDD TGONB TGON VDD pfet_03v3 ad=0.88p pd=4.88u as=0.88p ps=4.88u w=2u l=0.28u
X11 BUS TGON MID VSS nfet_03v3 ad=3.52p pd=16.88u as=3.52p ps=16.88u w=8u l=0.28u
X12 VSS SHON MID VSS nfet_03v3 ad=0.88p pd=4.88u as=0.88p ps=4.88u w=2u l=0.28u
X13 NNA SEL TGONB VSS nfet_03v3 ad=0.44p pd=2.88u as=0.44p ps=2.88u w=1u l=0.28u
X14 VSS VDD SEL VSS nfet_03v3 ad=0.1848p pd=1.72u as=0.1848p ps=1.72u w=0.42u l=20u
X15 BUS TGONB MID VDD pfet_03v3 ad=7.04p pd=32.88u as=7.04p ps=32.88u w=16u l=0.28u
X16 MID TGONB NODE VDD pfet_03v3 ad=7.04p pd=32.88u as=7.04p ps=32.88u w=16u l=0.28u
X17 VSS SD SHON VSS nfet_03v3 ad=0.44p pd=2.88u as=0.44p ps=2.88u w=1u l=0.28u
X18 VSS SEL SA VSS nfet_03v3 ad=0.1848p pd=1.72u as=0.1848p ps=1.72u w=0.42u l=2u
X19 VSS SA SD VSS nfet_03v3 ad=0.1848p pd=1.72u as=0.1848p ps=1.72u w=0.42u l=2u
C0 SHON MID 1.25101f
C1 SD VDD 4.80395f
C2 SA NNO 0.18456f
C3 SA TGONB 0.41663f
C4 SEL VDD 15.6829f
C5 BUS VDD 7.22687f
C6 SD NNO 0.29131f
C7 TGON VDD 2.45974f
C8 SD TGONB 6.52548f
C9 SEL NNO 1.45228f
C10 SEL TGONB 2.59045f
C11 BUS NNO 0.24147f
C12 SHON VDD 0.91342f
C13 BUS TGONB 1.07606f
C14 TGON NODE 0.121f
C15 TGON NNO 0.59412f
C16 TGON TGONB 2.41332f
C17 SHON NNO 1.27285f
C18 SHON TGONB 3.44024f
C19 MID VDD 3.62271f
C20 SD NNA 1.40471f
C21 SEL NNA 0.07593f
C22 MID NODE 4.0072f
C23 BUS NNA 0.2983f
C24 MID NNO 0.24849f
C25 MID TGONB 5.13095f
C26 NNA TGON 0.03087f
C27 SD SA 8.37889f
C28 SEL SA 6.87551f
C29 BUS SA 0.38342f
C30 TGON SA 0.46679f
C31 SEL SD 4.21946f
C32 VDD NODE 0.9065f
C33 BUS SD 0.73788f
C34 VDD NNO 2.10373f
C35 SHON SA 0.16199f
C36 VDD TGONB 6.32416f
C37 SEL BUS 0.66123f
C38 SD TGON 2.849f
C39 SEL TGON 0.77971f
C40 SHON SD 2.81021f
C41 NODE TGONB 1.52966f
C42 BUS TGON 0.68712f
C43 NNO TGONB 0.56238f
C44 SEL SHON 1.09836f
C45 MID SA 4.02195f
C46 SHON BUS 7.69115f
C47 SHON TGON 1.13806f
C48 NNA VDD 0.01294f
C49 MID SD 0.54864f
C50 SEL MID 8.59846f
C51 MID BUS 4.4327f
C52 NNA TGONB 0.82026f
C53 VDD SA 9.53195f
C54 MID TGON 10.1247f
C55 BUS VSS 11.828f
C56 NODE VSS 11.2543f
C57 NNA VSS 1.7205f
C58 SHON VSS 1.65714f
C59 NNO VSS 4.51101f
C60 SD VSS 21.22816f
C61 MID VSS 26.12901f
.ends
