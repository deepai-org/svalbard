* PEX produced on Wed Nov 25 12:26:58 AM CET 2026 using /foss/tools/sak/sak-pex.sh with m=2 and s=1
* NGSPICE file created from atb_pad_pex.ext - technology: gf180mcuD

.subckt atb_pad_pex PAD BUS SEL VDD VSS
X0 PAD VDD VMAX VMAX pfet_03v3 ad=0.88p pd=4.88u as=0.88p ps=4.88u w=2u l=0.28u
X1 VDD SEL TGONB VDD pfet_03v3 ad=0.44p pd=2.88u as=0.44p ps=2.88u w=1u l=0.28u
X2 VDD PAD VMAX VMAX pfet_03v3 ad=0.88p pd=4.88u as=0.88p ps=4.88u w=2u l=0.28u
X3 NNA SEL TGONB VSS nfet_03v3 ad=0.44p pd=2.88u as=0.44p ps=2.88u w=1u l=0.28u
X4 NNO SD SHON VDD pfet_03v3 ad=0.88p pd=4.88u as=0.88p ps=4.88u w=2u l=0.28u
X5 VDD SEL NNO VDD pfet_03v3 ad=0.88p pd=4.88u as=0.88p ps=4.88u w=2u l=0.28u
X6 VSS SD SHON VSS nfet_03v3 ad=0.44p pd=2.88u as=0.44p ps=2.88u w=1u l=0.28u
D0 VSS SEL diode_nd2ps_03v3 pj=14u area=12.25p
X7 VSS SHON BUS VSS nfet_03v3 ad=0.88p pd=4.88u as=0.88p ps=4.88u w=2u l=0.28u
X8 VDD TGONB TGON VDD pfet_03v3 ad=0.88p pd=4.88u as=0.88p ps=4.88u w=2u l=0.28u
X9 VSS VDD SEL VSS nfet_03v3 ad=0.1848p pd=1.72u as=0.1848p ps=1.72u w=0.42u l=20u
X10 VDD SD TGONB VDD pfet_03v3 ad=0.44p pd=2.88u as=0.44p ps=2.88u w=1u l=0.28u
X11 VDD SA SD VDD pfet_03v3 ad=0.3696p pd=2.56u as=0.3696p ps=2.56u w=0.84u l=2u
X12 VSS SEL SA VSS nfet_03v3 ad=0.1848p pd=1.72u as=0.1848p ps=1.72u w=0.42u l=2u
X13 VSS SA SD VSS nfet_03v3 ad=0.1848p pd=1.72u as=0.1848p ps=1.72u w=0.42u l=2u
X14 VSS SEL SHON VSS nfet_03v3 ad=0.44p pd=2.88u as=0.44p ps=2.88u w=1u l=0.28u
X15 BUS GP PAD VMAX pfet_03v3 ad=7.04p pd=32.88u as=7.04p ps=32.88u w=16u l=0.28u
X16 VMAX TGON GP VMAX pfet_03v3 ad=0.44p pd=2.88u as=0.44p ps=2.88u w=1u l=0.28u
X17 VDD SEL SA VDD pfet_03v3 ad=0.3696p pd=2.56u as=0.3696p ps=2.56u w=0.84u l=2u
X18 BUS TGON PAD VSS nfet_03v3 ad=3.52p pd=16.88u as=3.52p ps=16.88u w=8u l=0.28u
X19 VSS TGONB TGON VSS nfet_03v3 ad=0.44p pd=2.88u as=0.44p ps=2.88u w=1u l=0.28u
X20 VSS SD NNA VSS nfet_03v3 ad=0.44p pd=2.88u as=0.44p ps=2.88u w=1u l=0.28u
X21 VSS TGON GP VSS nfet_03v3 ad=0.44p pd=2.88u as=0.44p ps=2.88u w=1u l=0.28u
C0 SA NNO 0.19007f
C1 SEL TGONB 3.67602f
C2 PAD TGONB 0.59972f
C3 TGON TGONB 5.37168f
C4 VDD GP 4.55508f
C5 SA SHON 0.46206f
C6 GP SEL 0.51982f
C7 PAD GP 2.1695f
C8 NNA SD 2.23597f
C9 SA TGONB 0.55413f
C10 VDD SEL 13.6167f
C11 VDD PAD 4.53841f
C12 GP TGON 2.27502f
C13 BUS NNA 0.1796f
C14 VDD TGON 2.56887f
C15 PAD SEL 0.59987f
C16 SA GP 0.43723f
C17 TGON SEL 1.31259f
C18 PAD TGON 1.0002f
C19 VDD SA 6.41953f
C20 BUS SD 0.66896f
C21 SA SEL 6.4214f
C22 SA PAD 0.38191f
C23 SA TGON 0.47013f
C24 VMAX GP 2.07613f
C25 VDD VMAX 4.07101f
C26 VMAX SEL 0.12265f
C27 VMAX PAD 5.64731f
C28 NNO SD 0.44795f
C29 NNA TGONB 1.32206f
C30 VMAX TGON 0.96103f
C31 NNO BUS 0.19007f
C32 SHON SD 4.27028f
C33 BUS SHON 1.21964f
C34 TGONB SD 10.4187f
C35 VDD NNA 0.24227f
C36 BUS TGONB 0.60002f
C37 SEL NNA 0.28181f
C38 PAD NNA 0.05653f
C39 GP SD 0.51445f
C40 TGON NNA 0.20961f
C41 VDD SD 4.80846f
C42 GP BUS 4.91752f
C43 SEL SD 3.36884f
C44 PAD SD 0.47901f
C45 VDD BUS 1.13156f
C46 SA NNA 0.184f
C47 NNO SHON 1.79404f
C48 TGON SD 0.78262f
C49 BUS SEL 9.83013f
C50 PAD BUS 4.65531f
C51 NNO TGONB 0.20839f
C52 BUS TGON 8.35106f
C53 SA SD 9.30822f
C54 SHON TGONB 4.33937f
C55 SA BUS 3.16952f
C56 GP NNO 0.19007f
C57 VDD NNO 2.52891f
C58 GP SHON 3.70185f
C59 NNO SEL 2.36847f
C60 PAD NNO 0.21401f
C61 VDD SHON 1.13637f
C62 NNO TGON 0.6755f
C63 GP TGONB 0.51797f
C64 VMAX BUS 1.25133f
C65 SHON SEL 1.34863f
C66 PAD SHON 0.50049f
C67 VDD TGONB 4.92704f
C68 SHON TGON 0.98062f
C69 BUS VSS 16.26951f
C70 PAD VSS 2.66439f
C71 VDD VSS 4.52221f
C72 NNA VSS 8.12818f
C73 NNO VSS 5.87938f
C74 GP VSS 9.99121f
C75 VMAX VSS 0.18325p
.ends
