* NGSPICE file created from atb_leaf_f_flat.ext - technology: gf180mcuD

.subckt atb_leaf_f_flat NODE BUS SEL VDD VSS
X0 BUS SEL MID VSS nfet_03v3 ad=1.76p pd=8.88u as=1.76p ps=8.88u w=4u l=0.28u
X1 MID SEL NODE VSS nfet_03v3 ad=1.76p pd=8.88u as=1.76p ps=8.88u w=4u l=0.5u
X2 VSS SWB MID VSS nfet_03v3 ad=0.44p pd=2.88u as=0.44p ps=2.88u w=1u l=0.28u
D0 VSS SEL diode_nd2ps_03v3 pj=14p area=12.25p
X3 VSS SEL SWB VSS nfet_03v3 ad=0.22p pd=1.88u as=0.22p ps=1.88u w=0.5u l=0.28u
X4 BUS SWB MID VDD pfet_03v3 ad=3.52p pd=16.88u as=3.52p ps=16.88u w=8u l=0.28u
X5 VDD SEL SWB VDD pfet_03v3 ad=0.44p pd=2.88u as=0.44p ps=2.88u w=1u l=0.28u
X6 MID SWB NODE VDD pfet_03v3 ad=3.52p pd=16.88u as=3.52p ps=16.88u w=8u l=0.5u
C0 SWB NODE 0.96374f
C1 MID BUS 2.84475f
C2 MID NODE 1.2594f
C3 SWB MID 5.67612f
C4 SEL VDD 1.23678f
C5 VDD BUS 2.73466f
C6 NODE VDD 0.57035f
C7 SEL BUS 2.52697f
C8 SWB VDD 2.79544f
C9 SEL NODE 0.12067f
C10 MID VDD 1.38799f
C11 SWB SEL 1.78725f
C12 SWB BUS 3.42632f
C13 MID SEL 6.28259f
C14 BUS VSS 4.36674f
C15 SEL VSS 8.82008f
C16 NODE VSS 1.29125f
C17 VDD VSS 33.5392f
C18 MID VSS 3.73033f ; **FLOATING
C19 SWB VSS 3.95147f ; **FLOATING
.ends
