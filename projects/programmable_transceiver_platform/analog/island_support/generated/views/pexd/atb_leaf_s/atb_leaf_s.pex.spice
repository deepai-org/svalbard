* NGSPICE file created from atb_leaf_s_flat.ext - technology: gf180mcuD

.subckt atb_leaf_s_flat NODE BUS SEL VDD VSS
X0 VSS SWB MID VSS nfet_03v3 ad=0.44p pd=2.88u as=0.44p ps=2.88u w=1u l=0.28u
X1 BUS SWB MID VDD pfet_03v3 ad=0.88p pd=4.88u as=0.88p ps=4.88u w=2u l=0.28u
X2 BUS SEL MID VSS nfet_03v3 ad=0.44p pd=2.88u as=0.44p ps=2.88u w=1u l=0.28u
X3 VDD SEL SWB VDD pfet_03v3 ad=0.44p pd=2.88u as=0.44p ps=2.88u w=1u l=0.28u
X4 MID SEL NODE VSS nfet_03v3 ad=0.1848p pd=1.72u as=0.1848p ps=1.72u w=0.42u l=0.28u
D0 VSS SEL diode_nd2ps_03v3 pj=14p area=12.25p
X5 MID SWB NODE VDD pfet_03v3 ad=0.3696p pd=2.56u as=0.3696p ps=2.56u w=0.84u l=0.28u
X6 VSS SEL SWB VSS nfet_03v3 ad=0.22p pd=1.88u as=0.22p ps=1.88u w=0.5u l=0.28u
C0 SEL VDD 1.09746f
C1 SWB VDD 2.33221f
C2 NODE SEL 0.06748f
C3 SEL BUS 2.51034f
C4 MID VDD 0.85791f
C5 SWB NODE 0.44621f
C6 SWB BUS 2.64982f
C7 MID NODE 0.37139f
C8 SWB SEL 1.57772f
C9 MID BUS 1.57118f
C10 MID SEL 5.48859f
C11 SWB MID 4.84619f
C12 NODE VDD 0.31811f
C13 VDD BUS 2.4289f
C14 BUS VSS 3.86357f
C15 NODE VSS 1.10148f
C16 SEL VSS 8.67383f
C17 VDD VSS 18.4901f
C18 MID VSS 3.33718f ; **FLOATING
C19 SWB VSS 3.68892f ; **FLOATING
.ends
