* NGSPICE file created from atb_pad_flat.ext - technology: gf180mcuD

.subckt atb_pad_flat PAD BUS SEL VDD VSS
X0 PAD VDD VMAX VMAX pfet_03v3 ad=0.88p pd=4.88u as=0.88p ps=4.88u w=2u l=0.28u
X1 VDD SEL TGONB VDD pfet_03v3 ad=0.44p pd=2.88u as=0.44p ps=2.88u w=1u l=0.28u
X2 VDD PAD VMAX VMAX pfet_03v3 ad=0.88p pd=4.88u as=0.88p ps=4.88u w=2u l=0.28u
X3 NNA SEL TGONB VSS nfet_03v3 ad=0.44p pd=2.88u as=0.44p ps=2.88u w=1u l=0.28u
X4 NNO SD SHON VDD pfet_03v3 ad=0.88p pd=4.88u as=0.88p ps=4.88u w=2u l=0.28u
X5 VDD SEL NNO VDD pfet_03v3 ad=0.88p pd=4.88u as=0.88p ps=4.88u w=2u l=0.28u
X6 VSS SD SHON VSS nfet_03v3 ad=0.44p pd=2.88u as=0.44p ps=2.88u w=1u l=0.28u
D0 VSS SEL diode_nd2ps_03v3 pj=14p area=12.25p
X7 VSS SHON BUS VSS nfet_03v3 ad=0.88p pd=4.88u as=0.88p ps=4.88u w=2u l=0.28u
X8 VDD TGONB TGON VDD pfet_03v3 ad=0.88p pd=4.88u as=0.88p ps=4.88u w=2u l=0.28u
X9 VSS VDD SEL VSS nfet_03v3 ad=0.1848p pd=1.72u as=0.1848p ps=1.72u w=0.42u l=20u
X10 VDD SD TGONB VDD pfet_03v3 ad=0.44p pd=2.88u as=0.44p ps=2.88u w=1u l=0.28u
X11 VDD SA SD VDD pfet_03v3 ad=0.3696p pd=2.56u as=0.3696p ps=2.56u w=0.84u l=2u
X12 VSS SEL SA VSS nfet_03v3 ad=0.1848p pd=1.72u as=0.1848p ps=1.72u w=0.42u l=2u
X13 VSS SA SD VSS nfet_03v3 ad=0.1848p pd=1.72u as=0.1848p ps=1.72u w=0.42u l=2u
X14 VSS SEL SHON VSS nfet_03v3 ad=0.44p pd=2.88u as=0.44p ps=2.88u w=1u l=0.28u
X15 BUS GP PAD VMAX pfet_03v3 ad=7.04p pd=32.88u as=7.04p ps=32.88u w=16u l=0.28u
X16 VMAX TGON GP VMAX pfet_03v3 ad=0.44p pd=2.88u as=0.44p ps=2.88u w=1u l=0.28u
X17 VDD SEL SA VDD pfet_03v3 ad=0.3696p pd=2.56u as=0.3696p ps=2.56u w=0.84u l=2u
X18 BUS TGON PAD VSS nfet_03v3 ad=3.52p pd=16.88u as=3.52p ps=16.88u w=8u l=0.28u
X19 VSS TGONB TGON VSS nfet_03v3 ad=0.44p pd=2.88u as=0.44p ps=2.88u w=1u l=0.28u
X20 VSS SD NNA VSS nfet_03v3 ad=0.44p pd=2.88u as=0.44p ps=2.88u w=1u l=0.28u
X21 VSS TGON GP VSS nfet_03v3 ad=0.44p pd=2.88u as=0.44p ps=2.88u w=1u l=0.28u
C0 BUS SD 0.66896f
C1 SA SEL 6.4214f
C2 SA PAD 0.38191f
C3 SA TGON 0.47013f
C4 VMAX GP 2.07613f
C5 VDD VMAX 4.07101f
C6 VMAX SEL 0.12265f
C7 VMAX PAD 5.64731f
C8 NNO SD 0.44795f
C9 NNA TGONB 1.32206f
C10 VMAX TGON 0.96103f
C11 NNO BUS 0.19007f
C12 SHON SD 4.27028f
C13 BUS SHON 1.21964f
C14 TGONB SD 10.4187f
C15 VDD NNA 0.24227f
C16 BUS TGONB 0.60002f
C17 SEL NNA 0.28181f
C18 PAD NNA 0.05653f
C19 GP SD 0.51445f
C20 TGON NNA 0.20961f
C21 VDD SD 4.80846f
C22 GP BUS 4.91752f
C23 SEL SD 3.36884f
C24 PAD SD 0.47901f
C25 VDD BUS 1.13156f
C26 SA NNA 0.184f
C27 NNO SHON 1.79404f
C28 TGON SD 0.78262f
C29 BUS SEL 9.83013f
C30 PAD BUS 4.65531f
C31 NNO TGONB 0.20839f
C32 BUS TGON 8.35106f
C33 SA SD 9.30822f
C34 SHON TGONB 4.33937f
C35 SA BUS 3.16952f
C36 GP NNO 0.19007f
C37 VDD NNO 2.52891f
C38 GP SHON 3.70185f
C39 NNO SEL 2.36847f
C40 PAD NNO 0.21401f
C41 VDD SHON 1.13637f
C42 NNO TGON 0.6755f
C43 GP TGONB 0.51797f
C44 VMAX BUS 1.25133f
C45 SHON SEL 1.34863f
C46 PAD SHON 0.50049f
C47 VDD TGONB 4.92704f
C48 SHON TGON 0.98062f
C49 SA NNO 0.19007f
C50 SEL TGONB 3.67602f
C51 PAD TGONB 0.59972f
C52 TGON TGONB 5.37168f
C53 VDD GP 4.55508f
C54 SA SHON 0.46206f
C55 GP SEL 0.51982f
C56 PAD GP 2.1695f
C57 NNA SD 2.23597f
C58 SA TGONB 0.55413f
C59 VDD SEL 13.6167f
C60 VDD PAD 4.53841f
C61 GP TGON 2.27502f
C62 BUS NNA 0.1796f
C63 VDD TGON 2.56887f
C64 PAD SEL 0.59987f
C65 SA GP 0.43723f
C66 TGON SEL 1.31259f
C67 PAD TGON 1.0002f
C68 VDD SA 6.41953f
C69 SEL VSS 12.4986f
C70 BUS VSS 7.1881f
C71 PAD VSS 11.4533f
C72 VDD VSS 0.13577p
C73 NNA VSS 2.5966f ; **FLOATING
C74 SHON VSS 9.06678f ; **FLOATING
C75 NNO VSS 2.11211f ; **FLOATING
C76 SA VSS 9.04441f ; **FLOATING
C77 SD VSS 7.53454f ; **FLOATING
C78 TGONB VSS 6.56654f ; **FLOATING
C79 TGON VSS 13.5745f ; **FLOATING
C80 GP VSS 5.32878f ; **FLOATING
C81 VMAX VSS 65.7058f ; **FLOATING
.ends
