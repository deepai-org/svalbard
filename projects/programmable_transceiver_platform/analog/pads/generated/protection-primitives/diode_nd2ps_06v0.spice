* NGSPICE file created from diode_nd2ps_06v0.ext - technology: gf180mcuD

.subckt diode_nd2ps_06v0 A K
D0 A K diode_nd2ps_06v0 pj=51.8u area=22.5p
C0 K A 4.77743f
.ends
