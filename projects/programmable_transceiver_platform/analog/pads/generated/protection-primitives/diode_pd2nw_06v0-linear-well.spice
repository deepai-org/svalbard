* NGSPICE file created from diode_pd2nw_06v0.ext - technology: gf180mcuD

.subckt diode_pd2nw_06v0 A K SUB
D0 A K diode_pd2nw_06v0 pj=51.8u area=22.5p
C0 A K 5.25529f
C1 K SUB 12.8497f
.ends
