.subckt receive_control_guard VDD VSS RESET QUALIFIED CONFLICT REQ_TERM_ENABLE REQ_DIFF_ENABLE REQ_DIV_ENABLE REQ_BYPASS_ENABLE REQ_HS_P REQ_HS_N REQ_FS_HIGH_P REQ_FS_HIGH_N REQ_FS_LOW_P REQ_FS_LOW_N REQ_PULLUP_P REQ_PULLUP_N REQ_PULLDOWN_P REQ_PULLDOWN_N TERM_ENABLE DIFF_ENABLE DIV_ENABLE BYPASS_ENABLE HS_P HS_N FS_HIGH_P FS_HIGH_N FS_LOW_P FS_LOW_N PULLUP_P PULLUP_N PULLDOWN_P PULLDOWN_N
BCONFLICT CONFLICT VSS V=(((V(REQ_DIV_ENABLE,VSS)>1.65)*(V(REQ_BYPASS_ENABLE,VSS)>1.65))+((V(REQ_DIFF_ENABLE,VSS)>1.65)*(V(REQ_TERM_ENABLE,VSS)>1.65))+((V(REQ_DIFF_ENABLE,VSS)>1.65)*(V(REQ_FS_HIGH_P,VSS)>1.65))+((V(REQ_DIFF_ENABLE,VSS)>1.65)*(V(REQ_FS_HIGH_N,VSS)>1.65))+((V(REQ_TERM_ENABLE,VSS)>1.65)*(V(REQ_FS_HIGH_P,VSS)>1.65))+((V(REQ_TERM_ENABLE,VSS)>1.65)*(V(REQ_FS_HIGH_N,VSS)>1.65))+((V(REQ_DIFF_ENABLE,VSS)>1.65)*(V(REQ_FS_LOW_P,VSS)>1.65))+((V(REQ_DIFF_ENABLE,VSS)>1.65)*(V(REQ_FS_LOW_N,VSS)>1.65))+((V(REQ_HS_P,VSS)>1.65)*(V(REQ_FS_HIGH_P,VSS)>1.65))+((V(REQ_HS_P,VSS)>1.65)*(V(REQ_FS_HIGH_N,VSS)>1.65))+((V(REQ_HS_P,VSS)>1.65)*(V(REQ_FS_LOW_P,VSS)>1.65))+((V(REQ_HS_P,VSS)>1.65)*(V(REQ_FS_LOW_N,VSS)>1.65))+((V(REQ_HS_N,VSS)>1.65)*(V(REQ_FS_HIGH_P,VSS)>1.65))+((V(REQ_HS_N,VSS)>1.65)*(V(REQ_FS_HIGH_N,VSS)>1.65))+((V(REQ_HS_N,VSS)>1.65)*(V(REQ_FS_LOW_P,VSS)>1.65))+((V(REQ_HS_N,VSS)>1.65)*(V(REQ_FS_LOW_N,VSS)>1.65))+((V(REQ_FS_HIGH_P,VSS)>1.65)*(V(REQ_FS_LOW_P,VSS)>1.65))+((V(REQ_FS_HIGH_N,VSS)>1.65)*(V(REQ_FS_LOW_N,VSS)>1.65))>0)
BVALID VALID VSS V=(V(VDD,VSS)>=2.5)*(V(VDD,VSS)<=3.6)*(V(RESET,VSS)<1.65)*(V(QUALIFIED,VSS)>1.65)*(V(CONFLICT,VSS)<.5)
BTERM_ENABLE TERM_ENABLE VSS V=V(VDD,VSS)*V(VALID,VSS)*(V(REQ_TERM_ENABLE,VSS)>1.65)
BDIFF_ENABLE DIFF_ENABLE VSS V=V(VDD,VSS)*V(VALID,VSS)*(V(REQ_DIFF_ENABLE,VSS)>1.65)
BDIV_ENABLE DIV_ENABLE VSS V=V(VDD,VSS)*V(VALID,VSS)*(V(REQ_DIV_ENABLE,VSS)>1.65)
BBYPASS_ENABLE BYPASS_ENABLE VSS V=V(VDD,VSS)*V(VALID,VSS)*(V(REQ_BYPASS_ENABLE,VSS)>1.65)
BHS_P HS_P VSS V=V(VDD,VSS)*V(VALID,VSS)*(V(REQ_HS_P,VSS)>1.65)
BHS_N HS_N VSS V=V(VDD,VSS)*V(VALID,VSS)*(V(REQ_HS_N,VSS)>1.65)
BFS_HIGH_P FS_HIGH_P VSS V=V(VDD,VSS)*V(VALID,VSS)*(V(REQ_FS_HIGH_P,VSS)>1.65)
BFS_HIGH_N FS_HIGH_N VSS V=V(VDD,VSS)*V(VALID,VSS)*(V(REQ_FS_HIGH_N,VSS)>1.65)
BFS_LOW_P FS_LOW_P VSS V=V(VDD,VSS)*V(VALID,VSS)*(V(REQ_FS_LOW_P,VSS)>1.65)
BFS_LOW_N FS_LOW_N VSS V=V(VDD,VSS)*V(VALID,VSS)*(V(REQ_FS_LOW_N,VSS)>1.65)
BPULLUP_P PULLUP_P VSS V=V(VDD,VSS)*V(VALID,VSS)*(V(REQ_PULLUP_P,VSS)>1.65)
BPULLUP_N PULLUP_N VSS V=V(VDD,VSS)*V(VALID,VSS)*(V(REQ_PULLUP_N,VSS)>1.65)
BPULLDOWN_P PULLDOWN_P VSS V=V(VDD,VSS)*V(VALID,VSS)*(V(REQ_PULLDOWN_P,VSS)>1.65)
BPULLDOWN_N PULLDOWN_N VSS V=V(VDD,VSS)*V(VALID,VSS)*(V(REQ_PULLDOWN_N,VSS)>1.65)
.ends receive_control_guard
