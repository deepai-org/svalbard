.subckt tx_protected_pad PAD_P PAD_N VDD VSS TERM_VCM TERM_ENABLE DIFF_ENABLE DIV_ENABLE BYPASS_ENABLE RX_P RX_N HS_PBIAS HS_P HS_N FS_HIGH_P FS_HIGH_N FS_LOW_P FS_LOW_N PULLUP_P PULLUP_N PULLDOWN_P PULLDOWN_N
XPHYSICAL PAD_P PAD_N VDD VSS TERM_VCM TERM_ENABLE DIFF_ENABLE DIV_ENABLE BYPASS_ENABLE RX_P RX_N HS_PBIAS HS_P HS_N FS_HIGH_P FS_HIGH_N FS_LOW_P FS_LOW_N PULLUP_P PULLUP_N PULLDOWN_P PULLDOWN_N ESD_RAIL combined_flat
.ends tx_protected_pad
* NGSPICE file created from combined_flat.ext - technology: gf180mcuD

.subckt combined_flat PAD_P PAD_N VDD VSS TERM_VCM TERM_ENABLE DIFF_ENABLE DIV_ENABLE
+ BYPASS_ENABLE RX_P RX_N HS_PBIAS HS_P HS_N FS_HIGH_P FS_HIGH_N FS_LOW_P FS_LOW_N
+ PULLUP_P PULLUP_N PULLDOWN_P PULLDOWN_N ESD_RAIL
X0 ESD_RAIL a_42245_162628# VSS VSS nfet_06v0 ad=13p pd=50.52u as=13p ps=50.52u w=50u l=0.7u
X1 ESD_RAIL a_44789_189064# a_42245_162628# ESD_RAIL pfet_06v0 ad=1.3p pd=5.52u as=1.3p ps=5.52u w=5u l=0.7u
X2 VDD FS_N_GATE FS_N_WELL FS_N_WELL pfet_03v3 ad=6.16p pd=28.88u as=6.16p ps=28.88u w=14u l=0.28u
X3 TERM_P_R TERM_GATE_P TERM_VCM VSS nfet_03v3 ad=8.8p pd=40.88u as=8.8p ps=40.88u w=20u l=0.28u
X4 ESD_RAIL a_42245_162628# VSS VSS nfet_06v0 ad=13p pd=50.52u as=13p ps=50.52u w=50u l=0.7u
X5 HS_N_5 HS_N PAD_N VSS nfet_06v0 ad=8.8p pd=40.88u as=8.8p ps=40.88u w=20u l=0.7u
D0 VSS PAD_N diode_nd2ps_06v0 pj=51.8u area=22.5p
X6 TERM_GATE_P TERM_GATE_P_BLEED_0 VSS ppolyf_u_1k r_width=1u r_length=12.5u
X7 FS_P_CONTROL_S VDD VSS VSS nfet_03v3 ad=1.76p pd=8.88u as=1.76p ps=8.88u w=4u l=0.28u
X8 HS_P_4 HS_PBIAS VDD VDD pfet_03v3 ad=8.8p pd=40.88u as=8.8p ps=40.88u w=20u l=1u
X9 TERM_N_R TERM_GATE_N TERM_VCM VSS nfet_03v3 ad=8.8p pd=40.88u as=8.8p ps=40.88u w=20u l=0.28u
X10 VSS a_42245_162628# ESD_RAIL VSS nfet_06v0 ad=13p pd=50.52u as=22p ps=0.10088m w=50u l=0.7u
X11 TERM_P_R TERM_GATE_P TERM_VCM VSS nfet_03v3 ad=8.8p pd=40.88u as=8.8p ps=40.88u w=20u l=0.28u
X12 VSS a_42245_162628# ESD_RAIL VSS nfet_06v0 ad=13p pd=50.52u as=13p ps=50.52u w=50u l=0.7u
X13 VDD FS_P_GATE FS_P_WELL FS_P_WELL pfet_03v3 ad=6.16p pd=28.88u as=6.16p ps=28.88u w=14u l=0.28u
X14 PULLUP_N_OUT PULLUP_N_GATE PULLUP_N_WELL PULLUP_N_WELL pfet_03v3 ad=8.8p pd=40.88u as=8.8p ps=40.88u w=20u l=0.28u
X15 HS_N_4 HS_N PAD_N VSS nfet_06v0 ad=8.8p pd=40.88u as=8.8p ps=40.88u w=20u l=0.7u
X16 ESD_RAIL a_42245_162628# VSS VSS nfet_06v0 ad=22p pd=0.10088m as=13p ps=50.52u w=50u l=0.7u
X17 TERM_N_R TERM_GATE_N TERM_VCM VSS nfet_03v3 ad=8.8p pd=40.88u as=8.8p ps=40.88u w=20u l=0.28u
D1 VSS PAD_P diode_nd2ps_06v0 pj=51.8u area=22.5p
X18 ESD_RAIL a_42245_162628# VSS VSS nfet_06v0 ad=13p pd=50.52u as=13p ps=50.52u w=50u l=0.7u
X19 VDD FS_P_GATE FS_P_WELL FS_P_WELL pfet_03v3 ad=6.16p pd=28.88u as=6.16p ps=28.88u w=14u l=0.28u
X20 FS_N_OUT FS_N_GATE FS_N_WELL FS_N_WELL pfet_03v3 ad=6.16p pd=28.88u as=6.16p ps=28.88u w=14u l=0.28u
X21 FS_P_WELL FS_P_BLEED_0 VSS ppolyf_u_1k r_width=1u r_length=12.5u
X22 TERM_GATE_N TERM_GATE_N_BLEED_0 VSS ppolyf_u_1k r_width=1u r_length=12.5u
X23 FS_N_OUT FS_N_GATE FS_N_WELL FS_N_WELL pfet_03v3 ad=6.16p pd=28.88u as=6.16p ps=28.88u w=14u l=0.28u
X24 FS_P_OUT FS_P_GATE FS_P_WELL FS_P_WELL pfet_03v3 ad=6.16p pd=28.88u as=6.16p ps=28.88u w=14u l=0.28u
X25 TERM_OR_N_B FS_LOW_N TERM_OR_N_S VDD pfet_03v3 ad=1.76p pd=8.88u as=1.76p ps=8.88u w=4u l=0.28u
X26 PULLUP_P_BLEED_2 PULLUP_P_BLEED_3 VSS ppolyf_u_1k r_width=1u r_length=12.5u
X27 PULLUP_P_GATE VDD PULLUP_P_WELL PULLUP_P_WELL pfet_03v3 ad=1.76p pd=8.88u as=1.76p ps=8.88u w=4u l=0.28u
X28 PULLUP_N_OUT PULLUP_N_GATE PULLUP_N_WELL PULLUP_N_WELL pfet_03v3 ad=8.8p pd=40.88u as=8.8p ps=40.88u w=20u l=0.28u
X29 ESD_RAIL a_42245_162628# VSS VSS nfet_06v0 ad=13p pd=50.52u as=13p ps=50.52u w=50u l=0.7u
X30 ESD_RAIL a_42245_162628# VSS VSS nfet_06v0 ad=13p pd=50.52u as=13p ps=50.52u w=50u l=0.7u
X31 ESD_RAIL a_41005_203545# a_43813_189064# ESD_RAIL pfet_06v0 ad=1.3p pd=5.52u as=1.3p ps=5.52u w=5u l=0.7u
X32 VSS a_42245_162628# ESD_RAIL VSS nfet_06v0 ad=13p pd=50.52u as=13p ps=50.52u w=50u l=0.7u
X33 FS_P_OUT FS_P_GATE FS_P_WELL FS_P_WELL pfet_03v3 ad=6.16p pd=28.88u as=6.16p ps=28.88u w=14u l=0.28u
X34 FS_N_WELL FS_N_BLEED_0 VSS ppolyf_u_1k r_width=1u r_length=12.5u
X35 HS_P_9 HS_PBIAS VDD VDD pfet_03v3 ad=8.8p pd=40.88u as=8.8p ps=40.88u w=20u l=1u
D2 VSS PAD_N diode_nd2ps_06v0 pj=51.8u area=22.5p
X36 a_42245_162628# a_44789_189064# ESD_RAIL ESD_RAIL pfet_06v0 ad=1.3p pd=5.52u as=1.3p ps=5.52u w=5u l=0.7u
X37 FS_P_OUT FS_P_GATE FS_P_WELL FS_P_WELL pfet_03v3 ad=6.16p pd=28.88u as=6.16p ps=28.88u w=14u l=0.28u
X38 HS_N_9 HS_N PAD_N VSS nfet_06v0 ad=8.8p pd=40.88u as=8.8p ps=40.88u w=20u l=0.7u
X39 FS_N_OUT FS_N_GATE FS_N_WELL FS_N_WELL pfet_03v3 ad=6.16p pd=28.88u as=6.16p ps=28.88u w=14u l=0.28u
X40 FS_P_OUT FS_P_GATE FS_P_WELL FS_P_WELL pfet_03v3 ad=6.16p pd=28.88u as=6.16p ps=28.88u w=14u l=0.28u
X41 VSS a_42245_162628# ESD_RAIL VSS nfet_06v0 ad=13p pd=50.52u as=13p ps=50.52u w=50u l=0.7u
X42 a_41005_204385# a_53878_204105# ESD_RAIL ppolyf_u r_width=0.8u r_length=63.855u
X43 ESD_RAIL a_42245_162628# VSS VSS nfet_06v0 ad=13p pd=50.52u as=13p ps=50.52u w=50u l=0.7u
X44 ESD_RAIL a_42245_162628# VSS VSS nfet_06v0 ad=13p pd=50.52u as=13p ps=50.52u w=50u l=0.7u
X45 HS_P_7 HS_PBIAS VDD VDD pfet_03v3 ad=8.8p pd=40.88u as=8.8p ps=40.88u w=20u l=1u
X46 PULLUP_P_GATE PULLUP_P PULLUP_P_CONTROL_S VSS nfet_06v0 ad=0.88p pd=4.88u as=0.88p ps=4.88u w=2u l=0.7u
X47 HS_P_11 HS_P PAD_P VSS nfet_06v0 ad=8.8p pd=40.88u as=8.8p ps=40.88u w=20u l=0.7u
X48 PULLUP_N_CONTROL_S VDD VSS VSS nfet_03v3 ad=1.76p pd=8.88u as=1.76p ps=8.88u w=4u l=0.28u
X49 TERM_P_R TERM_GATE_P TERM_VCM VSS nfet_03v3 ad=8.8p pd=40.88u as=8.8p ps=40.88u w=20u l=0.28u
X50 PAD_P PULLDOWN_P_R VSS ppolyf_u_1k r_width=1u r_length=14.2u
D3 VSS PAD_P diode_nd2ps_06v0 pj=51.8u area=22.5p
X51 ESD_RAIL a_42245_162628# VSS VSS nfet_06v0 ad=13p pd=50.52u as=13p ps=50.52u w=50u l=0.7u
X52 ESD_RAIL a_42245_162628# VSS VSS nfet_06v0 ad=13p pd=50.52u as=13p ps=50.52u w=50u l=0.7u
X53 a_42245_162628# a_44789_189064# ESD_RAIL ESD_RAIL pfet_06v0 ad=1.3p pd=5.52u as=1.3p ps=5.52u w=5u l=0.7u
X54 PAD_P BYPASS_ENABLE RX_P VSS nfet_06v0 ad=8.8p pd=40.88u as=8.8p ps=40.88u w=20u l=0.7u
X55 HS_N_6 HS_N PAD_N VSS nfet_06v0 ad=8.8p pd=40.88u as=8.8p ps=40.88u w=20u l=0.7u
X56 FS_N_OUT FS_N_GATE FS_N_WELL FS_N_WELL pfet_03v3 ad=6.16p pd=28.88u as=6.16p ps=28.88u w=14u l=0.28u
X57 FS_P_OUT FS_P_GATE FS_P_WELL FS_P_WELL pfet_03v3 ad=6.16p pd=28.88u as=6.16p ps=28.88u w=14u l=0.28u
D4 VSS ESD_RAIL diode_nd2ps_06v0 pj=82u area=40p
X58 DIV_LOW_P DIV_ENABLE VSS VSS nfet_03v3 ad=8.8p pd=40.88u as=8.8p ps=40.88u w=20u l=0.28u
X59 FS_N_OUT FS_N_GATE FS_N_WELL FS_N_WELL pfet_03v3 ad=6.16p pd=28.88u as=6.16p ps=28.88u w=14u l=0.28u
X60 FS_P_OUT FS_P_GATE FS_P_WELL FS_P_WELL pfet_03v3 ad=6.16p pd=28.88u as=6.16p ps=28.88u w=14u l=0.28u
X61 HS_N_7 HS_N PAD_N VSS nfet_06v0 ad=8.8p pd=40.88u as=8.8p ps=40.88u w=20u l=0.7u
X62 a_42245_162628# a_44789_189064# ESD_RAIL ESD_RAIL pfet_06v0 ad=1.3p pd=5.52u as=1.3p ps=5.52u w=5u l=0.7u
X63 FS_P_OUT FS_P_GATE FS_P_WELL FS_P_WELL pfet_03v3 ad=6.16p pd=28.88u as=6.16p ps=28.88u w=14u l=0.28u
X64 PULLUP_P_OUT PULLUP_P_GATE PULLUP_P_WELL PULLUP_P_WELL pfet_03v3 ad=8.8p pd=40.88u as=8.8p ps=40.88u w=20u l=0.28u
X65 ESD_RAIL a_44789_189064# a_42245_162628# ESD_RAIL pfet_06v0 ad=1.3p pd=5.52u as=1.3p ps=5.52u w=5u l=0.7u
X66 TERM_P_R DIFF_ENABLE TERM_N_R VSS nfet_03v3 ad=8.8p pd=40.88u as=8.8p ps=40.88u w=20u l=0.28u
X67 VSS a_42245_162628# ESD_RAIL VSS nfet_06v0 ad=13p pd=50.52u as=13p ps=50.52u w=50u l=0.7u
X68 HS_N_2 HS_N PAD_N VSS nfet_06v0 ad=8.8p pd=40.88u as=8.8p ps=40.88u w=20u l=0.7u
X69 TERM_OR_N_B FS_LOW_N TERM_OR_N_NS VSS nfet_03v3 ad=0.88p pd=4.88u as=0.88p ps=4.88u w=2u l=0.28u
X70 FS_N_OUT FS_N_GATE FS_N_WELL FS_N_WELL pfet_03v3 ad=6.16p pd=28.88u as=6.16p ps=28.88u w=14u l=0.28u
X71 VSS a_42245_162628# ESD_RAIL VSS nfet_06v0 ad=13p pd=50.52u as=13p ps=50.52u w=50u l=0.7u
X72 VSS a_42245_162628# ESD_RAIL VSS nfet_06v0 ad=13p pd=50.52u as=13p ps=50.52u w=50u l=0.7u
X73 HS_N_7 HS_PBIAS VDD VDD pfet_03v3 ad=8.8p pd=40.88u as=8.8p ps=40.88u w=20u l=1u
X74 PULLUP_N_OUT PULLUP_N_GATE PULLUP_N_WELL PULLUP_N_WELL pfet_03v3 ad=8.8p pd=40.88u as=8.8p ps=40.88u w=20u l=0.28u
X75 a_42245_162628# a_44789_189064# VSS VSS nfet_06v0 ad=1.3p pd=5.52u as=1.3p ps=5.52u w=5u l=0.7u
X76 ESD_RAIL a_44789_189064# a_42245_162628# ESD_RAIL pfet_06v0 ad=1.3p pd=5.52u as=1.3p ps=5.52u w=5u l=0.7u
X77 a_42245_162628# a_44789_189064# ESD_RAIL ESD_RAIL pfet_06v0 ad=1.3p pd=5.52u as=1.3p ps=5.52u w=5u l=0.7u
X78 ESD_RAIL a_41005_203545# a_43813_189064# ESD_RAIL pfet_06v0 ad=1.3p pd=5.52u as=1.3p ps=5.52u w=5u l=0.7u
X79 FS_P_BLEED_1 FS_P_BLEED_2 VSS ppolyf_u_1k r_width=1u r_length=12.5u
X80 HS_N_9 HS_PBIAS VDD VDD pfet_03v3 ad=8.8p pd=40.88u as=8.8p ps=40.88u w=20u l=1u
X81 PULLUP_N_BLEED_5 PULLUP_N_BLEED_6 VSS ppolyf_u_1k r_width=1u r_length=12.5u
X82 FS_N_OUT PAD_N VSS ppolyf_s r_width=2u r_length=3.5u
X83 FS_P_OUT FS_P_GATE FS_P_WELL FS_P_WELL pfet_03v3 ad=6.16p pd=28.88u as=6.16p ps=28.88u w=14u l=0.28u
X84 a_41005_203825# a_53878_204105# ESD_RAIL ppolyf_u r_width=0.8u r_length=63.855u
X85 TERM_P_R DIFF_ENABLE TERM_N_R VSS nfet_03v3 ad=8.8p pd=40.88u as=8.8p ps=40.88u w=20u l=0.28u
X86 TERM_OR_P_S TERM_ENABLE VDD VDD pfet_03v3 ad=1.76p pd=8.88u as=1.76p ps=8.88u w=4u l=0.28u
X87 FS_P_BLEED_3 FS_P_BLEED_4 VSS ppolyf_u_1k r_width=1u r_length=12.5u
X88 FS_P_OUT FS_P_GATE FS_P_WELL FS_P_WELL pfet_03v3 ad=6.16p pd=28.88u as=6.16p ps=28.88u w=14u l=0.28u
X89 PULLUP_P_OUT PULLUP_P_GATE PULLUP_P_WELL PULLUP_P_WELL pfet_03v3 ad=8.8p pd=40.88u as=8.8p ps=40.88u w=20u l=0.28u
X90 a_42245_162628# a_44789_189064# ESD_RAIL ESD_RAIL pfet_06v0 ad=1.3p pd=5.52u as=1.3p ps=5.52u w=5u l=0.7u
X91 FS_N_OUT FS_N_GATE FS_N_WELL FS_N_WELL pfet_03v3 ad=6.16p pd=28.88u as=6.16p ps=28.88u w=14u l=0.28u
X92 HS_N_13 HS_N PAD_N VSS nfet_06v0 ad=8.8p pd=40.88u as=8.8p ps=40.88u w=20u l=0.7u
X93 ESD_RAIL a_42245_162628# VSS VSS nfet_06v0 ad=13p pd=50.52u as=13p ps=50.52u w=50u l=0.7u
X94 ESD_RAIL a_42245_162628# VSS VSS nfet_06v0 ad=13p pd=50.52u as=13p ps=50.52u w=50u l=0.7u
X95 ESD_RAIL a_42245_162628# VSS VSS nfet_06v0 ad=13p pd=50.52u as=13p ps=50.52u w=50u l=0.7u
X96 FS_P_OUT FS_P_GATE FS_P_WELL FS_P_WELL pfet_03v3 ad=6.16p pd=28.88u as=6.16p ps=28.88u w=14u l=0.28u
X97 HS_N_3 HS_PBIAS VDD VDD pfet_03v3 ad=8.8p pd=40.88u as=8.8p ps=40.88u w=20u l=1u
X98 VCM_LOW_OK TERM_VCM VDD VDD pfet_03v3 ad=0.88p pd=4.88u as=0.88p ps=4.88u w=2u l=0.28u
X99 PULLUP_N_BLEED_3 PULLUP_N_BLEED_4 VSS ppolyf_u_1k r_width=1u r_length=12.5u
X100 ESD_RAIL a_42245_162628# VSS VSS nfet_06v0 ad=13p pd=50.52u as=13p ps=50.52u w=50u l=0.7u
X101 HS_P_11 HS_PBIAS VDD VDD pfet_03v3 ad=8.8p pd=40.88u as=8.8p ps=40.88u w=20u l=1u
D5 PAD_N ESD_RAIL diode_pd2nw_06v0 pj=51.8u area=22.5p
X102 a_41005_204945# a_53878_205225# ESD_RAIL ppolyf_u r_width=0.8u r_length=63.855u
X103 a_42245_162628# a_44789_189064# ESD_RAIL ESD_RAIL pfet_06v0 ad=1.3p pd=5.52u as=1.3p ps=5.52u w=5u l=0.7u
X104 FS_P_OUT FS_P_GATE FS_P_WELL FS_P_WELL pfet_03v3 ad=6.16p pd=28.88u as=6.16p ps=28.88u w=14u l=0.28u
X105 FS_N_GATE FS_HIGH_N FS_N_CONTROL_S VSS nfet_06v0 ad=0.88p pd=4.88u as=0.88p ps=4.88u w=2u l=0.7u
X106 PULLUP_P_OUT PAD_P VSS ppolyf_u_1k r_width=1u r_length=1.18u
X107 FS_P_OUT FS_P_GATE FS_P_WELL FS_P_WELL pfet_03v3 ad=6.16p pd=28.88u as=6.16p ps=28.88u w=14u l=0.28u
X108 VSS a_42245_162628# ESD_RAIL VSS nfet_06v0 ad=13p pd=50.52u as=13p ps=50.52u w=50u l=0.7u
X109 VDD FS_N_GATE FS_N_WELL FS_N_WELL pfet_03v3 ad=6.16p pd=28.88u as=6.16p ps=28.88u w=14u l=0.28u
X110 HS_P_3 HS_PBIAS VDD VDD pfet_03v3 ad=8.8p pd=40.88u as=8.8p ps=40.88u w=20u l=1u
X111 FS_P_OUT FS_P_GATE FS_P_WELL FS_P_WELL pfet_03v3 ad=6.16p pd=28.88u as=6.16p ps=28.88u w=14u l=0.28u
X112 FS_N_BLEED_2 FS_N_BLEED_3 VSS ppolyf_u_1k r_width=1u r_length=12.5u
X113 VSS a_42245_162628# ESD_RAIL VSS nfet_06v0 ad=13p pd=50.52u as=13p ps=50.52u w=50u l=0.7u
X114 VSS a_42245_162628# ESD_RAIL VSS nfet_06v0 ad=13p pd=50.52u as=22p ps=0.10088m w=50u l=0.7u
X115 VSS a_44789_189064# a_42245_162628# VSS nfet_06v0 ad=2.2p pd=10.88u as=1.3p ps=5.52u w=5u l=0.7u
X116 ESD_RAIL a_44789_189064# a_42245_162628# ESD_RAIL pfet_06v0 ad=1.3p pd=5.52u as=1.3p ps=5.52u w=5u l=0.7u
X117 a_42245_162628# a_44789_189064# ESD_RAIL ESD_RAIL pfet_06v0 ad=1.3p pd=5.52u as=1.3p ps=5.52u w=5u l=0.7u
X118 PULLUP_P_CONTROL_S VDD VSS VSS nfet_03v3 ad=1.76p pd=8.88u as=1.76p ps=8.88u w=4u l=0.28u
X119 VSS a_42245_162628# ESD_RAIL VSS nfet_06v0 ad=13p pd=50.52u as=13p ps=50.52u w=50u l=0.7u
X120 ESD_RAIL a_44789_189064# a_42245_162628# ESD_RAIL pfet_06v0 ad=1.3p pd=5.52u as=1.3p ps=5.52u w=5u l=0.7u
X121 ESD_RAIL a_42245_162628# VSS VSS nfet_06v0 ad=22p pd=0.10088m as=13p ps=50.52u w=50u l=0.7u
X122 FS_P_OUT FS_P_GATE FS_P_WELL FS_P_WELL pfet_03v3 ad=6.16p pd=28.88u as=6.16p ps=28.88u w=14u l=0.28u
X123 FS_P_OUT FS_P_GATE FS_P_WELL FS_P_WELL pfet_03v3 ad=6.16p pd=28.88u as=6.16p ps=28.88u w=14u l=0.28u
X124 a_41005_206065# a_53878_206345# ESD_RAIL ppolyf_u r_width=0.8u r_length=63.855u
X125 VDD FS_N_GATE FS_N_WELL FS_N_WELL pfet_03v3 ad=6.16p pd=28.88u as=6.16p ps=28.88u w=14u l=0.28u
X126 VDD FS_N_GATE FS_N_WELL FS_N_WELL pfet_03v3 ad=6.16p pd=28.88u as=6.16p ps=28.88u w=14u l=0.28u
X127 a_42245_162628# a_44789_189064# VSS VSS nfet_06v0 ad=1.3p pd=5.52u as=1.3p ps=5.52u w=5u l=0.7u
X128 ESD_RAIL a_44789_189064# a_42245_162628# ESD_RAIL pfet_06v0 ad=1.3p pd=5.52u as=1.3p ps=5.52u w=5u l=0.7u
X129 TERM_OR_N_S TERM_ENABLE VDD VDD pfet_03v3 ad=1.76p pd=8.88u as=1.76p ps=8.88u w=4u l=0.28u
X130 a_42245_162628# a_44789_189064# ESD_RAIL ESD_RAIL pfet_06v0 ad=1.3p pd=5.52u as=2.2p ps=10.88u w=5u l=0.7u
X131 HS_P_13 HS_PBIAS VDD VDD pfet_03v3 ad=8.8p pd=40.88u as=8.8p ps=40.88u w=20u l=1u
X132 a_43813_189064# a_41005_203545# VSS VSS nfet_06v0 ad=2.2p pd=10.88u as=2.2p ps=10.88u w=5u l=0.7u
X133 ESD_RAIL a_42245_162628# VSS VSS nfet_06v0 ad=13p pd=50.52u as=13p ps=50.52u w=50u l=0.7u
X134 PAD_N DIV_N VSS ppolyf_u_1k r_width=1u r_length=2u
X135 ESD_RAIL VSS cap_mim_2f0_m4m5_noshield c_width=31.6u c_length=31.6u
X136 TERM_GATE_N_BLEED_2 VSS VSS ppolyf_u_1k r_width=1u r_length=12.5u
X137 ESD_RAIL a_42245_162628# VSS VSS nfet_06v0 ad=13p pd=50.52u as=13p ps=50.52u w=50u l=0.7u
X138 ESD_RAIL a_42245_162628# VSS VSS nfet_06v0 ad=13p pd=50.52u as=13p ps=50.52u w=50u l=0.7u
X139 a_42245_162628# a_44789_189064# VSS VSS nfet_06v0 ad=1.3p pd=5.52u as=1.3p ps=5.52u w=5u l=0.7u
X140 VSS a_42245_162628# ESD_RAIL VSS nfet_06v0 ad=13p pd=50.52u as=13p ps=50.52u w=50u l=0.7u
X141 PULLUP_P_BLEED_5 PULLUP_P_BLEED_6 VSS ppolyf_u_1k r_width=1u r_length=12.5u
X142 VSS a_43813_189064# a_44789_189064# VSS nfet_06v0 ad=1.3p pd=5.52u as=1.3p ps=5.52u w=5u l=0.7u
X143 a_42245_162628# a_44789_189064# ESD_RAIL ESD_RAIL pfet_06v0 ad=1.3p pd=5.52u as=1.3p ps=5.52u w=5u l=0.7u
X144 VDD FS_N_GATE FS_N_WELL FS_N_WELL pfet_03v3 ad=6.16p pd=28.88u as=6.16p ps=28.88u w=14u l=0.28u
X145 VDD FS_N_GATE FS_N_WELL FS_N_WELL pfet_03v3 ad=6.16p pd=28.88u as=6.16p ps=28.88u w=14u l=0.28u
X146 FS_P_OUT FS_P_GATE FS_P_WELL FS_P_WELL pfet_03v3 ad=6.16p pd=28.88u as=6.16p ps=28.88u w=14u l=0.28u
X147 VDD FS_N_GATE FS_N_WELL FS_N_WELL pfet_03v3 ad=6.16p pd=28.88u as=6.16p ps=28.88u w=14u l=0.28u
D6 PAD_P ESD_RAIL diode_pd2nw_06v0 pj=51.8u area=22.5p
D7 PAD_N ESD_RAIL diode_pd2nw_06v0 pj=51.8u area=22.5p
X148 VSS a_43813_189064# a_44789_189064# VSS nfet_06v0 ad=1.3p pd=5.52u as=1.3p ps=5.52u w=5u l=0.7u
X149 TERM_OR_P_B VCM_LOW_OK TERM_OR_P_S VDD pfet_03v3 ad=1.76p pd=8.88u as=1.76p ps=8.88u w=4u l=0.28u
X150 VCM_LOW_OK TERM_VCM VSS VSS nfet_03v3 ad=3.52p pd=16.88u as=3.52p ps=16.88u w=8u l=0.28u
X151 VSS ESD_RAIL VSS ppolyf_u_1k_6p0 r_width=1u r_length=9.98874m
X152 TERM_GATE_P_BLEED_2 VSS VSS ppolyf_u_1k r_width=1u r_length=12.5u
X153 PAD_P TERM_P_R VSS ppolyf_s r_width=1u r_length=3.29u
X154 VDD FS_N_GATE FS_N_WELL FS_N_WELL pfet_03v3 ad=6.16p pd=28.88u as=6.16p ps=28.88u w=14u l=0.28u
X155 FS_N_GATE VDD FS_N_WELL FS_N_WELL pfet_03v3 ad=1.76p pd=8.88u as=1.76p ps=8.88u w=4u l=0.28u
X156 VSS a_42245_162628# ESD_RAIL VSS nfet_06v0 ad=13p pd=50.52u as=13p ps=50.52u w=50u l=0.7u
X157 ESD_RAIL a_42245_162628# VSS VSS nfet_06v0 ad=13p pd=50.52u as=13p ps=50.52u w=50u l=0.7u
X158 HS_N_12 HS_PBIAS VDD VDD pfet_03v3 ad=8.8p pd=40.88u as=8.8p ps=40.88u w=20u l=1u
X159 PULLUP_N_GATE VDD PULLUP_N_WELL PULLUP_N_WELL pfet_03v3 ad=1.76p pd=8.88u as=1.76p ps=8.88u w=4u l=0.28u
X160 HS_P_10 HS_P PAD_P VSS nfet_06v0 ad=8.8p pd=40.88u as=8.8p ps=40.88u w=20u l=0.7u
X161 VDD FS_N_GATE FS_N_WELL FS_N_WELL pfet_03v3 ad=6.16p pd=28.88u as=6.16p ps=28.88u w=14u l=0.28u
X162 TERM_P_R TERM_GATE_P TERM_VCM VSS nfet_03v3 ad=8.8p pd=40.88u as=8.8p ps=40.88u w=20u l=0.28u
X163 PAD_N PULLDOWN_N_R VSS ppolyf_u_1k r_width=1u r_length=14.2u
X164 PAD_P BYPASS_ENABLE RX_P VSS nfet_06v0 ad=8.8p pd=40.88u as=8.8p ps=40.88u w=20u l=0.7u
X165 HS_P_5 HS_P PAD_P VSS nfet_06v0 ad=8.8p pd=40.88u as=8.8p ps=40.88u w=20u l=0.7u
X166 VDD FS_N_GATE FS_N_WELL FS_N_WELL pfet_03v3 ad=6.16p pd=28.88u as=6.16p ps=28.88u w=14u l=0.28u
X167 DIV_P DIV_ENABLE RX_P VSS nfet_06v0 ad=8.8p pd=40.88u as=8.8p ps=40.88u w=20u l=0.7u
X168 ESD_RAIL a_42245_162628# VSS VSS nfet_06v0 ad=13p pd=50.52u as=13p ps=50.52u w=50u l=0.7u
X169 HS_P_6 HS_P PAD_P VSS nfet_06v0 ad=8.8p pd=40.88u as=8.8p ps=40.88u w=20u l=0.7u
X170 VDD FS_N_GATE FS_N_WELL FS_N_WELL pfet_03v3 ad=6.16p pd=28.88u as=6.16p ps=28.88u w=14u l=0.28u
D8 PAD_P ESD_RAIL diode_pd2nw_06v0 pj=51.8u area=22.5p
X171 VSS a_42245_162628# ESD_RAIL VSS nfet_06v0 ad=13p pd=50.52u as=13p ps=50.52u w=50u l=0.7u
X172 VSS a_42245_162628# ESD_RAIL VSS nfet_06v0 ad=13p pd=50.52u as=13p ps=50.52u w=50u l=0.7u
X173 VDD FS_N_GATE FS_N_WELL FS_N_WELL pfet_03v3 ad=6.16p pd=28.88u as=6.16p ps=28.88u w=14u l=0.28u
X174 VSS a_42245_162628# ESD_RAIL VSS nfet_06v0 ad=13p pd=50.52u as=13p ps=50.52u w=50u l=0.7u
X175 DIV_LOW_N DIV_ENABLE VSS VSS nfet_03v3 ad=8.8p pd=40.88u as=8.8p ps=40.88u w=20u l=0.28u
X176 VDD PULLUP_N_GATE PULLUP_N_WELL PULLUP_N_WELL pfet_03v3 ad=8.8p pd=40.88u as=8.8p ps=40.88u w=20u l=0.28u
X177 TERM_P_R TERM_GATE_P TERM_VCM VSS nfet_03v3 ad=8.8p pd=40.88u as=8.8p ps=40.88u w=20u l=0.28u
X178 HS_P_3 HS_P PAD_P VSS nfet_06v0 ad=8.8p pd=40.88u as=8.8p ps=40.88u w=20u l=0.7u
X179 FS_P_BLEED_0 FS_P_BLEED_1 VSS ppolyf_u_1k r_width=1u r_length=12.5u
X180 VDD FS_P_GATE FS_P_WELL FS_P_WELL pfet_03v3 ad=6.16p pd=28.88u as=6.16p ps=28.88u w=14u l=0.28u
X181 VSS a_42245_162628# ESD_RAIL VSS nfet_06v0 ad=13p pd=50.52u as=13p ps=50.52u w=50u l=0.7u
D9 VSS ESD_RAIL diode_nd2ps_06v0 pj=82u area=40p
X182 TERM_GATE_N TERM_OR_N_B VSS VSS nfet_03v3 ad=1.76p pd=8.88u as=1.76p ps=8.88u w=4u l=0.28u
X183 FS_P_BLEED_2 FS_P_BLEED_3 VSS ppolyf_u_1k r_width=1u r_length=12.5u
X184 VDD FS_P_GATE FS_P_WELL FS_P_WELL pfet_03v3 ad=6.16p pd=28.88u as=6.16p ps=28.88u w=14u l=0.28u
D10 VSS ESD_RAIL diode_nd2ps_06v0 pj=82u area=40p
X185 VDD PULLUP_P_GATE PULLUP_P_WELL PULLUP_P_WELL pfet_03v3 ad=8.8p pd=40.88u as=8.8p ps=40.88u w=20u l=0.28u
D11 VSS ESD_RAIL diode_nd2ps_06v0 pj=82u area=40p
X186 ESD_RAIL a_42245_162628# VSS VSS nfet_06v0 ad=13p pd=50.52u as=13p ps=50.52u w=50u l=0.7u
X187 TERM_N_R TERM_GATE_N TERM_VCM VSS nfet_03v3 ad=8.8p pd=40.88u as=8.8p ps=40.88u w=20u l=0.28u
X188 PULLDOWN_N_R PULLDOWN_N VSS VSS nfet_03v3 ad=3.52p pd=16.88u as=3.52p ps=16.88u w=8u l=0.28u
X189 HS_P_12 HS_P PAD_P VSS nfet_06v0 ad=8.8p pd=40.88u as=8.8p ps=40.88u w=20u l=0.7u
X190 ESD_RAIL a_42245_162628# VSS VSS nfet_06v0 ad=13p pd=50.52u as=13p ps=50.52u w=50u l=0.7u
X191 VDD FS_N_GATE FS_N_WELL FS_N_WELL pfet_03v3 ad=6.16p pd=28.88u as=6.16p ps=28.88u w=14u l=0.28u
X192 HS_N_2 HS_PBIAS VDD VDD pfet_03v3 ad=8.8p pd=40.88u as=8.8p ps=40.88u w=20u l=1u
X193 VDD PULLUP_N_GATE PULLUP_N_WELL PULLUP_N_WELL pfet_03v3 ad=8.8p pd=40.88u as=8.8p ps=40.88u w=20u l=0.28u
X194 FS_N_BLEED_3 FS_N_BLEED_4 VSS ppolyf_u_1k r_width=1u r_length=12.5u
X195 DIV_N DIV_ENABLE RX_N VSS nfet_06v0 ad=8.8p pd=40.88u as=8.8p ps=40.88u w=20u l=0.7u
X196 a_41005_203825# a_53878_203545# ESD_RAIL ppolyf_u r_width=0.8u r_length=63.855u
X197 FS_P_GATE FS_HIGH_P FS_P_CONTROL_S VSS nfet_06v0 ad=0.88p pd=4.88u as=0.88p ps=4.88u w=2u l=0.7u
X198 HS_P_10 HS_PBIAS VDD VDD pfet_03v3 ad=8.8p pd=40.88u as=8.8p ps=40.88u w=20u l=1u
X199 VDD FS_P_GATE FS_P_WELL FS_P_WELL pfet_03v3 ad=6.16p pd=28.88u as=6.16p ps=28.88u w=14u l=0.28u
X200 a_44789_189064# a_43813_189064# VSS VSS nfet_06v0 ad=1.3p pd=5.52u as=2.2p ps=10.88u w=5u l=0.7u
X201 VSS RX_P VSS ppolyf_u_1k_6p0 r_width=1u r_length=0.31954m
X202 TERM_N_R TERM_GATE_N TERM_VCM VSS nfet_03v3 ad=8.8p pd=40.88u as=8.8p ps=40.88u w=20u l=0.28u
X203 VDD FS_P_GATE FS_P_WELL FS_P_WELL pfet_03v3 ad=6.16p pd=28.88u as=6.16p ps=28.88u w=14u l=0.28u
X204 VSS a_42245_162628# ESD_RAIL VSS nfet_06v0 ad=13p pd=50.52u as=13p ps=50.52u w=50u l=0.7u
X205 PULLUP_N_OUT PAD_N VSS ppolyf_u_1k r_width=1u r_length=1.18u
X206 VDD FS_P_GATE FS_P_WELL FS_P_WELL pfet_03v3 ad=6.16p pd=28.88u as=6.16p ps=28.88u w=14u l=0.28u
X207 VSS a_42245_162628# ESD_RAIL VSS nfet_06v0 ad=13p pd=50.52u as=13p ps=50.52u w=50u l=0.7u
X208 PULLUP_N_GATE PULLUP_N PULLUP_N_CONTROL_S VSS nfet_06v0 ad=0.88p pd=4.88u as=0.88p ps=4.88u w=2u l=0.7u
X209 VSS a_42245_162628# ESD_RAIL VSS nfet_06v0 ad=13p pd=50.52u as=13p ps=50.52u w=50u l=0.7u
X210 VDD FS_P_GATE FS_P_WELL FS_P_WELL pfet_03v3 ad=6.16p pd=28.88u as=6.16p ps=28.88u w=14u l=0.28u
X211 FS_N_BLEED_1 FS_N_BLEED_2 VSS ppolyf_u_1k r_width=1u r_length=12.5u
X212 a_41005_204945# a_53878_204665# ESD_RAIL ppolyf_u r_width=0.8u r_length=63.855u
X213 PULLUP_P_BLEED_0 PULLUP_P_BLEED_1 VSS ppolyf_u_1k r_width=1u r_length=12.5u
X214 VDD FS_N_GATE FS_N_WELL FS_N_WELL pfet_03v3 ad=6.16p pd=28.88u as=6.16p ps=28.88u w=14u l=0.28u
X215 HS_P_6 HS_PBIAS VDD VDD pfet_03v3 ad=8.8p pd=40.88u as=8.8p ps=40.88u w=20u l=1u
X216 FS_N_OUT FS_N_GATE FS_N_WELL FS_N_WELL pfet_03v3 ad=6.16p pd=28.88u as=6.16p ps=28.88u w=14u l=0.28u
X217 FS_N_OUT FS_N_GATE FS_N_WELL FS_N_WELL pfet_03v3 ad=6.16p pd=28.88u as=6.16p ps=28.88u w=14u l=0.28u
X218 ESD_RAIL a_42245_162628# VSS VSS nfet_06v0 ad=13p pd=50.52u as=13p ps=50.52u w=50u l=0.7u
X219 VDD FS_P_GATE FS_P_WELL FS_P_WELL pfet_03v3 ad=6.16p pd=28.88u as=6.16p ps=28.88u w=14u l=0.28u
X220 HS_P_12 HS_PBIAS VDD VDD pfet_03v3 ad=8.8p pd=40.88u as=8.8p ps=40.88u w=20u l=1u
X221 VDD FS_P_GATE FS_P_WELL FS_P_WELL pfet_03v3 ad=6.16p pd=28.88u as=6.16p ps=28.88u w=14u l=0.28u
X222 ESD_RAIL a_42245_162628# VSS VSS nfet_06v0 ad=13p pd=50.52u as=13p ps=50.52u w=50u l=0.7u
X223 VSS a_42245_162628# ESD_RAIL VSS nfet_06v0 ad=13p pd=50.52u as=13p ps=50.52u w=50u l=0.7u
X224 PULLUP_N_BLEED_0 PULLUP_N_BLEED_1 VSS ppolyf_u_1k r_width=1u r_length=12.5u
X225 TERM_GATE_N_BLEED_1 TERM_GATE_N_BLEED_2 VSS ppolyf_u_1k r_width=1u r_length=12.5u
X226 ESD_RAIL a_44789_189064# a_42245_162628# ESD_RAIL pfet_06v0 ad=1.3p pd=5.52u as=1.3p ps=5.52u w=5u l=0.7u
X227 PULLUP_P_BLEED_4 PULLUP_P_BLEED_5 VSS ppolyf_u_1k r_width=1u r_length=12.5u
X228 FS_N_OUT FS_N_GATE FS_N_WELL FS_N_WELL pfet_03v3 ad=6.16p pd=28.88u as=6.16p ps=28.88u w=14u l=0.28u
X229 VDD FS_P_GATE FS_P_WELL FS_P_WELL pfet_03v3 ad=6.16p pd=28.88u as=6.16p ps=28.88u w=14u l=0.28u
X230 FS_N_CONTROL_S VDD VSS VSS nfet_03v3 ad=1.76p pd=8.88u as=1.76p ps=8.88u w=4u l=0.28u
X231 FS_N_OUT FS_N_GATE FS_N_WELL FS_N_WELL pfet_03v3 ad=6.16p pd=28.88u as=6.16p ps=28.88u w=14u l=0.28u
X232 TERM_GATE_P TERM_OR_P_B VSS VSS nfet_03v3 ad=1.76p pd=8.88u as=1.76p ps=8.88u w=4u l=0.28u
X233 HS_N_8 HS_N PAD_N VSS nfet_06v0 ad=8.8p pd=40.88u as=8.8p ps=40.88u w=20u l=0.7u
X234 HS_N_13 HS_PBIAS VDD VDD pfet_03v3 ad=8.8p pd=40.88u as=8.8p ps=40.88u w=20u l=1u
X235 PULLUP_N_BLEED_6 PULLUP_N_GATE VSS ppolyf_u_1k r_width=1u r_length=12.5u
X236 VSS a_42245_162628# ESD_RAIL VSS nfet_06v0 ad=13p pd=50.52u as=13p ps=50.52u w=50u l=0.7u
X237 TERM_OR_P_B FS_LOW_P TERM_OR_P_S VDD pfet_03v3 ad=1.76p pd=8.88u as=1.76p ps=8.88u w=4u l=0.28u
X238 VSS a_42245_162628# ESD_RAIL VSS nfet_06v0 ad=13p pd=50.52u as=22p ps=0.10088m w=50u l=0.7u
X239 VSS a_42245_162628# ESD_RAIL VSS nfet_06v0 ad=13p pd=50.52u as=13p ps=50.52u w=50u l=0.7u
X240 TERM_P_R DIFF_ENABLE TERM_N_R VSS nfet_03v3 ad=8.8p pd=40.88u as=8.8p ps=40.88u w=20u l=0.28u
X241 FS_N_OUT FS_N_GATE FS_N_WELL FS_N_WELL pfet_03v3 ad=6.16p pd=28.88u as=6.16p ps=28.88u w=14u l=0.28u
X242 VSS a_42245_162628# ESD_RAIL VSS nfet_06v0 ad=13p pd=50.52u as=22p ps=0.10088m w=50u l=0.7u
X243 a_43813_189064# a_41005_203545# ESD_RAIL ESD_RAIL pfet_06v0 ad=1.3p pd=5.52u as=1.3p ps=5.52u w=5u l=0.7u
X244 a_42245_162628# a_44789_189064# ESD_RAIL ESD_RAIL pfet_06v0 ad=1.3p pd=5.52u as=1.3p ps=5.52u w=5u l=0.7u
X245 TERM_GATE_P TERM_OR_P_B VDD VDD pfet_03v3 ad=3.52p pd=16.88u as=3.52p ps=16.88u w=8u l=0.28u
X246 VSS RX_N VSS ppolyf_u_1k_6p0 r_width=1u r_length=0.31954m
X247 HS_N_11 HS_PBIAS VDD VDD pfet_03v3 ad=8.8p pd=40.88u as=8.8p ps=40.88u w=20u l=1u
X248 a_41005_203545# VSS cap_mim_2f0_m4m5_noshield c_width=31.6u c_length=31.6u
X249 TERM_OR_P_B FS_LOW_P TERM_OR_P_NS VSS nfet_03v3 ad=0.88p pd=4.88u as=0.88p ps=4.88u w=2u l=0.28u
X250 FS_N_BLEED_5 FS_N_BLEED_6 VSS ppolyf_u_1k r_width=1u r_length=12.5u
X251 VSS a_42245_162628# ESD_RAIL VSS nfet_06v0 ad=13p pd=50.52u as=13p ps=50.52u w=50u l=0.7u
X252 a_44789_189064# a_43813_189064# ESD_RAIL ESD_RAIL pfet_06v0 ad=2.2p pd=10.88u as=1.3p ps=5.52u w=5u l=0.7u
X253 a_41005_206065# a_53878_205785# ESD_RAIL ppolyf_u r_width=0.8u r_length=63.855u
X254 PULLUP_N_BLEED_2 PULLUP_N_BLEED_3 VSS ppolyf_u_1k r_width=1u r_length=12.5u
X255 FS_P_BLEED_5 FS_P_BLEED_6 VSS ppolyf_u_1k r_width=1u r_length=12.5u
D12 VSS PAD_N diode_nd2ps_06v0 pj=51.8u area=22.5p
X256 ESD_RAIL a_42245_162628# VSS VSS nfet_06v0 ad=13p pd=50.52u as=13p ps=50.52u w=50u l=0.7u
X257 FS_P_OUT FS_P_GATE FS_P_WELL FS_P_WELL pfet_03v3 ad=6.16p pd=28.88u as=6.16p ps=28.88u w=14u l=0.28u
X258 PULLUP_P_OUT PULLUP_P_GATE PULLUP_P_WELL PULLUP_P_WELL pfet_03v3 ad=8.8p pd=40.88u as=8.8p ps=40.88u w=20u l=0.28u
X259 FS_N_OUT FS_N_GATE FS_N_WELL FS_N_WELL pfet_03v3 ad=6.16p pd=28.88u as=6.16p ps=28.88u w=14u l=0.28u
X260 HS_N_1 HS_N PAD_N VSS nfet_06v0 ad=8.8p pd=40.88u as=8.8p ps=40.88u w=20u l=0.7u
X261 HS_N_5 HS_PBIAS VDD VDD pfet_03v3 ad=8.8p pd=40.88u as=8.8p ps=40.88u w=20u l=1u
X262 FS_N_OUT FS_N_GATE FS_N_WELL FS_N_WELL pfet_03v3 ad=6.16p pd=28.88u as=6.16p ps=28.88u w=14u l=0.28u
X263 ESD_RAIL a_44789_189064# a_42245_162628# ESD_RAIL pfet_06v0 ad=2.2p pd=10.88u as=1.3p ps=5.52u w=5u l=0.7u
X264 a_42245_162628# a_44789_189064# ESD_RAIL ESD_RAIL pfet_06v0 ad=1.3p pd=5.52u as=1.3p ps=5.52u w=5u l=0.7u
X265 VSS a_42245_162628# ESD_RAIL VSS nfet_06v0 ad=13p pd=50.52u as=13p ps=50.52u w=50u l=0.7u
X266 DIV_N DIV_LOW_N VSS ppolyf_u_1k r_width=1u r_length=2u
D13 VSS PAD_P diode_nd2ps_06v0 pj=51.8u area=22.5p
X267 HS_N_10 HS_N PAD_N VSS nfet_06v0 ad=8.8p pd=40.88u as=8.8p ps=40.88u w=20u l=0.7u
X268 TERM_P_R TERM_GATE_P TERM_VCM VSS nfet_03v3 ad=8.8p pd=40.88u as=8.8p ps=40.88u w=20u l=0.28u
X269 PAD_N BYPASS_ENABLE RX_N VSS nfet_06v0 ad=8.8p pd=40.88u as=8.8p ps=40.88u w=20u l=0.7u
X270 FS_N_OUT FS_N_GATE FS_N_WELL FS_N_WELL pfet_03v3 ad=6.16p pd=28.88u as=6.16p ps=28.88u w=14u l=0.28u
X271 VSS a_42245_162628# ESD_RAIL VSS nfet_06v0 ad=13p pd=50.52u as=13p ps=50.52u w=50u l=0.7u
X272 VSS a_42245_162628# ESD_RAIL VSS nfet_06v0 ad=13p pd=50.52u as=13p ps=50.52u w=50u l=0.7u
X273 ESD_RAIL a_44789_189064# a_42245_162628# ESD_RAIL pfet_06v0 ad=1.3p pd=5.52u as=1.3p ps=5.52u w=5u l=0.7u
X274 HS_N_3 HS_N PAD_N VSS nfet_06v0 ad=8.8p pd=40.88u as=8.8p ps=40.88u w=20u l=0.7u
X275 FS_N_OUT FS_N_GATE FS_N_WELL FS_N_WELL pfet_03v3 ad=6.16p pd=28.88u as=6.16p ps=28.88u w=14u l=0.28u
X276 PULLUP_N_OUT PULLUP_N_GATE PULLUP_N_WELL PULLUP_N_WELL pfet_03v3 ad=8.8p pd=40.88u as=8.8p ps=40.88u w=20u l=0.28u
X277 FS_N_OUT FS_N_GATE FS_N_WELL FS_N_WELL pfet_03v3 ad=6.16p pd=28.88u as=6.16p ps=28.88u w=14u l=0.28u
X278 FS_P_OUT FS_P_GATE FS_P_WELL FS_P_WELL pfet_03v3 ad=6.16p pd=28.88u as=6.16p ps=28.88u w=14u l=0.28u
X279 ESD_RAIL a_43813_189064# a_44789_189064# ESD_RAIL pfet_06v0 ad=1.3p pd=5.52u as=1.3p ps=5.52u w=5u l=0.7u
X280 FS_N_OUT FS_N_GATE FS_N_WELL FS_N_WELL pfet_03v3 ad=6.16p pd=28.88u as=6.16p ps=28.88u w=14u l=0.28u
X281 ESD_RAIL a_42245_162628# VSS VSS nfet_06v0 ad=13p pd=50.52u as=13p ps=50.52u w=50u l=0.7u
D14 VSS PAD_N diode_nd2ps_06v0 pj=51.8u area=22.5p
X282 TERM_N_R TERM_GATE_N TERM_VCM VSS nfet_03v3 ad=8.8p pd=40.88u as=8.8p ps=40.88u w=20u l=0.28u
X283 a_42245_162628# a_44789_189064# ESD_RAIL ESD_RAIL pfet_06v0 ad=1.3p pd=5.52u as=1.3p ps=5.52u w=5u l=0.7u
X284 ESD_RAIL a_42245_162628# VSS VSS nfet_06v0 ad=13p pd=50.52u as=13p ps=50.52u w=50u l=0.7u
X285 FS_N_OUT FS_N_GATE FS_N_WELL FS_N_WELL pfet_03v3 ad=6.16p pd=28.88u as=6.16p ps=28.88u w=14u l=0.28u
X286 a_43813_189064# a_41005_203545# ESD_RAIL ESD_RAIL pfet_06v0 ad=1.3p pd=5.52u as=2.2p ps=10.88u w=5u l=0.7u
X287 ESD_RAIL a_42245_162628# VSS VSS nfet_06v0 ad=22p pd=0.10088m as=13p ps=50.52u w=50u l=0.7u
X288 TERM_OR_N_B VCM_LOW_OK TERM_OR_N_S VDD pfet_03v3 ad=1.76p pd=8.88u as=1.76p ps=8.88u w=4u l=0.28u
X289 FS_P_OUT FS_P_GATE FS_P_WELL FS_P_WELL pfet_03v3 ad=6.16p pd=28.88u as=6.16p ps=28.88u w=14u l=0.28u
X290 ESD_RAIL a_42245_162628# VSS VSS nfet_06v0 ad=13p pd=50.52u as=13p ps=50.52u w=50u l=0.7u
X291 HS_N_1 HS_PBIAS VDD VDD pfet_03v3 ad=8.8p pd=40.88u as=8.8p ps=40.88u w=20u l=1u
X292 FS_P_OUT FS_P_GATE FS_P_WELL FS_P_WELL pfet_03v3 ad=6.16p pd=28.88u as=6.16p ps=28.88u w=14u l=0.28u
X293 HS_P_1 HS_PBIAS VDD VDD pfet_03v3 ad=8.8p pd=40.88u as=8.8p ps=40.88u w=20u l=1u
X294 PULLUP_P_BLEED_1 PULLUP_P_BLEED_2 VSS ppolyf_u_1k r_width=1u r_length=12.5u
X295 a_44789_189064# a_43813_189064# ESD_RAIL ESD_RAIL pfet_06v0 ad=1.3p pd=5.52u as=1.3p ps=5.52u w=5u l=0.7u
D15 VSS PAD_P diode_nd2ps_06v0 pj=51.8u area=22.5p
X296 TERM_N_R TERM_GATE_N TERM_VCM VSS nfet_03v3 ad=8.8p pd=40.88u as=8.8p ps=40.88u w=20u l=0.28u
X297 FS_N_OUT FS_N_GATE FS_N_WELL FS_N_WELL pfet_03v3 ad=6.16p pd=28.88u as=6.16p ps=28.88u w=14u l=0.28u
X298 VSS a_42245_162628# ESD_RAIL VSS nfet_06v0 ad=13p pd=50.52u as=13p ps=50.52u w=50u l=0.7u
X299 HS_P_0 HS_P PAD_P VSS nfet_06v0 ad=8.8p pd=40.88u as=8.8p ps=40.88u w=20u l=0.7u
X300 FS_P_OUT FS_P_GATE FS_P_WELL FS_P_WELL pfet_03v3 ad=6.16p pd=28.88u as=6.16p ps=28.88u w=14u l=0.28u
X301 FS_N_OUT FS_N_GATE FS_N_WELL FS_N_WELL pfet_03v3 ad=6.16p pd=28.88u as=6.16p ps=28.88u w=14u l=0.28u
X302 PAD_P BYPASS_ENABLE RX_P VSS nfet_06v0 ad=8.8p pd=40.88u as=8.8p ps=40.88u w=20u l=0.7u
X303 FS_P_OUT FS_P_GATE FS_P_WELL FS_P_WELL pfet_03v3 ad=6.16p pd=28.88u as=6.16p ps=28.88u w=14u l=0.28u
X304 FS_N_OUT FS_N_GATE FS_N_WELL FS_N_WELL pfet_03v3 ad=6.16p pd=28.88u as=6.16p ps=28.88u w=14u l=0.28u
X305 PULLUP_P_OUT PULLUP_P_GATE PULLUP_P_WELL PULLUP_P_WELL pfet_03v3 ad=8.8p pd=40.88u as=8.8p ps=40.88u w=20u l=0.28u
X306 PAD_P BYPASS_ENABLE RX_P VSS nfet_06v0 ad=8.8p pd=40.88u as=8.8p ps=40.88u w=20u l=0.7u
X307 VSS a_42245_162628# ESD_RAIL VSS nfet_06v0 ad=13p pd=50.52u as=13p ps=50.52u w=50u l=0.7u
X308 VSS a_42245_162628# ESD_RAIL VSS nfet_06v0 ad=13p pd=50.52u as=13p ps=50.52u w=50u l=0.7u
X309 ESD_RAIL a_44789_189064# a_42245_162628# ESD_RAIL pfet_06v0 ad=1.3p pd=5.52u as=1.3p ps=5.52u w=5u l=0.7u
X310 PULLUP_P_WELL PULLUP_P_BLEED_0 VSS ppolyf_u_1k r_width=1u r_length=12.5u
X311 FS_N_OUT FS_N_GATE FS_N_WELL FS_N_WELL pfet_03v3 ad=6.16p pd=28.88u as=6.16p ps=28.88u w=14u l=0.28u
D16 PAD_P ESD_RAIL diode_pd2nw_06v0 pj=51.8u area=22.5p
X312 HS_P_5 HS_PBIAS VDD VDD pfet_03v3 ad=8.8p pd=40.88u as=8.8p ps=40.88u w=20u l=1u
X313 ESD_RAIL a_42245_162628# VSS VSS nfet_06v0 ad=13p pd=50.52u as=13p ps=50.52u w=50u l=0.7u
X314 HS_P_8 HS_P PAD_P VSS nfet_06v0 ad=8.8p pd=40.88u as=8.8p ps=40.88u w=20u l=0.7u
X315 FS_P_OUT FS_P_GATE FS_P_WELL FS_P_WELL pfet_03v3 ad=6.16p pd=28.88u as=6.16p ps=28.88u w=14u l=0.28u
X316 FS_P_OUT FS_P_GATE FS_P_WELL FS_P_WELL pfet_03v3 ad=6.16p pd=28.88u as=6.16p ps=28.88u w=14u l=0.28u
X317 PULLUP_N_WELL PULLUP_N_BLEED_0 VSS ppolyf_u_1k r_width=1u r_length=12.5u
X318 ESD_RAIL a_42245_162628# VSS VSS nfet_06v0 ad=13p pd=50.52u as=13p ps=50.52u w=50u l=0.7u
X319 a_41005_203545# a_53878_203545# ESD_RAIL ppolyf_u r_width=0.8u r_length=63.855u
X320 FS_N_OUT FS_N_GATE FS_N_WELL FS_N_WELL pfet_03v3 ad=6.16p pd=28.88u as=6.16p ps=28.88u w=14u l=0.28u
X321 ESD_RAIL a_42245_162628# VSS VSS nfet_06v0 ad=13p pd=50.52u as=13p ps=50.52u w=50u l=0.7u
X322 VSS a_43813_189064# a_44789_189064# VSS nfet_06v0 ad=1.3p pd=5.52u as=1.3p ps=5.52u w=5u l=0.7u
X323 TERM_GATE_P_BLEED_0 TERM_GATE_P_BLEED_1 VSS ppolyf_u_1k r_width=1u r_length=12.5u
X324 HS_P_7 HS_P PAD_P VSS nfet_06v0 ad=8.8p pd=40.88u as=8.8p ps=40.88u w=20u l=0.7u
X325 VSS a_42245_162628# ESD_RAIL VSS nfet_06v0 ad=13p pd=50.52u as=13p ps=50.52u w=50u l=0.7u
X326 VSS a_42245_162628# ESD_RAIL VSS nfet_06v0 ad=13p pd=50.52u as=13p ps=50.52u w=50u l=0.7u
X327 FS_P_BLEED_6 FS_P_GATE VSS ppolyf_u_1k r_width=1u r_length=12.5u
X328 VSS a_44789_189064# a_42245_162628# VSS nfet_06v0 ad=1.3p pd=5.52u as=1.3p ps=5.52u w=5u l=0.7u
X329 VDD FS_P_GATE FS_P_WELL FS_P_WELL pfet_03v3 ad=6.16p pd=28.88u as=6.16p ps=28.88u w=14u l=0.28u
X330 VDD PULLUP_P_GATE PULLUP_P_WELL PULLUP_P_WELL pfet_03v3 ad=8.8p pd=40.88u as=8.8p ps=40.88u w=20u l=0.28u
X331 DIV_P DIV_LOW_P VSS ppolyf_u_1k r_width=1u r_length=2u
X332 VSS a_44789_189064# a_42245_162628# VSS nfet_06v0 ad=1.3p pd=5.52u as=1.3p ps=5.52u w=5u l=0.7u
X333 TERM_N_R TERM_GATE_N TERM_VCM VSS nfet_03v3 ad=8.8p pd=40.88u as=8.8p ps=40.88u w=20u l=0.28u
X334 TERM_P_R DIFF_ENABLE TERM_N_R VSS nfet_03v3 ad=8.8p pd=40.88u as=8.8p ps=40.88u w=20u l=0.28u
X335 TERM_OR_N_B TERM_ENABLE VSS VSS nfet_03v3 ad=0.88p pd=4.88u as=0.88p ps=4.88u w=2u l=0.28u
X336 HS_P_1 HS_P PAD_P VSS nfet_06v0 ad=8.8p pd=40.88u as=8.8p ps=40.88u w=20u l=0.7u
X337 ESD_RAIL a_44789_189064# a_42245_162628# ESD_RAIL pfet_06v0 ad=1.3p pd=5.52u as=1.3p ps=5.52u w=5u l=0.7u
X338 TERM_P_R TERM_GATE_P TERM_VCM VSS nfet_03v3 ad=8.8p pd=40.88u as=8.8p ps=40.88u w=20u l=0.28u
X339 VSS a_42245_162628# ESD_RAIL VSS nfet_06v0 ad=13p pd=50.52u as=13p ps=50.52u w=50u l=0.7u
X340 HS_N_6 HS_PBIAS VDD VDD pfet_03v3 ad=8.8p pd=40.88u as=8.8p ps=40.88u w=20u l=1u
X341 HS_P_4 HS_P PAD_P VSS nfet_06v0 ad=8.8p pd=40.88u as=8.8p ps=40.88u w=20u l=0.7u
X342 a_41005_204385# a_53878_204665# ESD_RAIL ppolyf_u r_width=0.8u r_length=63.855u
X343 TERM_N_R TERM_GATE_N TERM_VCM VSS nfet_03v3 ad=8.8p pd=40.88u as=8.8p ps=40.88u w=20u l=0.28u
X344 FS_P_GATE VDD FS_P_WELL FS_P_WELL pfet_03v3 ad=1.76p pd=8.88u as=1.76p ps=8.88u w=4u l=0.28u
X345 FS_N_BLEED_4 FS_N_BLEED_5 VSS ppolyf_u_1k r_width=1u r_length=12.5u
D17 PAD_N ESD_RAIL diode_pd2nw_06v0 pj=51.8u area=22.5p
X346 ESD_RAIL a_42245_162628# VSS VSS nfet_06v0 ad=13p pd=50.52u as=13p ps=50.52u w=50u l=0.7u
X347 a_44789_189064# a_43813_189064# VSS VSS nfet_06v0 ad=1.3p pd=5.52u as=1.3p ps=5.52u w=5u l=0.7u
D18 PAD_P ESD_RAIL diode_pd2nw_06v0 pj=51.8u area=22.5p
X348 ESD_RAIL a_42245_162628# VSS VSS nfet_06v0 ad=13p pd=50.52u as=13p ps=50.52u w=50u l=0.7u
X349 TERM_GATE_N_BLEED_0 TERM_GATE_N_BLEED_1 VSS ppolyf_u_1k r_width=1u r_length=12.5u
X350 PULLUP_N_BLEED_1 PULLUP_N_BLEED_2 VSS ppolyf_u_1k r_width=1u r_length=12.5u
X351 FS_P_BLEED_4 FS_P_BLEED_5 VSS ppolyf_u_1k r_width=1u r_length=12.5u
X352 VDD FS_P_GATE FS_P_WELL FS_P_WELL pfet_03v3 ad=6.16p pd=28.88u as=6.16p ps=28.88u w=14u l=0.28u
X353 VDD PULLUP_P_GATE PULLUP_P_WELL PULLUP_P_WELL pfet_03v3 ad=8.8p pd=40.88u as=8.8p ps=40.88u w=20u l=0.28u
X354 PULLUP_P_BLEED_3 PULLUP_P_BLEED_4 VSS ppolyf_u_1k r_width=1u r_length=12.5u
X355 FS_N_BLEED_6 FS_N_GATE VSS ppolyf_u_1k r_width=1u r_length=12.5u
X356 TERM_GATE_N TERM_OR_N_B VDD VDD pfet_03v3 ad=3.52p pd=16.88u as=3.52p ps=16.88u w=8u l=0.28u
X357 HS_P_13 HS_P PAD_P VSS nfet_06v0 ad=8.8p pd=40.88u as=8.8p ps=40.88u w=20u l=0.7u
X358 VDD PULLUP_N_GATE PULLUP_N_WELL PULLUP_N_WELL pfet_03v3 ad=8.8p pd=40.88u as=8.8p ps=40.88u w=20u l=0.28u
X359 HS_N_4 HS_PBIAS VDD VDD pfet_03v3 ad=8.8p pd=40.88u as=8.8p ps=40.88u w=20u l=1u
X360 VDD FS_P_GATE FS_P_WELL FS_P_WELL pfet_03v3 ad=6.16p pd=28.88u as=6.16p ps=28.88u w=14u l=0.28u
X361 a_41005_205505# a_53878_205785# ESD_RAIL ppolyf_u r_width=0.8u r_length=63.855u
X362 VDD FS_P_GATE FS_P_WELL FS_P_WELL pfet_03v3 ad=6.16p pd=28.88u as=6.16p ps=28.88u w=14u l=0.28u
X363 FS_N_BLEED_0 FS_N_BLEED_1 VSS ppolyf_u_1k r_width=1u r_length=12.5u
X364 ESD_RAIL a_42245_162628# VSS VSS nfet_06v0 ad=13p pd=50.52u as=13p ps=50.52u w=50u l=0.7u
X365 HS_N_12 HS_N PAD_N VSS nfet_06v0 ad=8.8p pd=40.88u as=8.8p ps=40.88u w=20u l=0.7u
X366 VSS a_42245_162628# ESD_RAIL VSS nfet_06v0 ad=13p pd=50.52u as=13p ps=50.52u w=50u l=0.7u
X367 PAD_N BYPASS_ENABLE RX_N VSS nfet_06v0 ad=8.8p pd=40.88u as=8.8p ps=40.88u w=20u l=0.7u
X368 VSS a_42245_162628# ESD_RAIL VSS nfet_06v0 ad=13p pd=50.52u as=13p ps=50.52u w=50u l=0.7u
X369 VDD FS_N_GATE FS_N_WELL FS_N_WELL pfet_03v3 ad=6.16p pd=28.88u as=6.16p ps=28.88u w=14u l=0.28u
X370 PULLDOWN_P_R PULLDOWN_P VSS VSS nfet_03v3 ad=3.52p pd=16.88u as=3.52p ps=16.88u w=8u l=0.28u
X371 VDD FS_N_GATE FS_N_WELL FS_N_WELL pfet_03v3 ad=6.16p pd=28.88u as=6.16p ps=28.88u w=14u l=0.28u
X372 HS_P_9 HS_P PAD_P VSS nfet_06v0 ad=8.8p pd=40.88u as=8.8p ps=40.88u w=20u l=0.7u
X373 VDD PULLUP_N_GATE PULLUP_N_WELL PULLUP_N_WELL pfet_03v3 ad=8.8p pd=40.88u as=8.8p ps=40.88u w=20u l=0.28u
X374 VDD FS_N_GATE FS_N_WELL FS_N_WELL pfet_03v3 ad=6.16p pd=28.88u as=6.16p ps=28.88u w=14u l=0.28u
X375 VDD FS_P_GATE FS_P_WELL FS_P_WELL pfet_03v3 ad=6.16p pd=28.88u as=6.16p ps=28.88u w=14u l=0.28u
D19 PAD_N ESD_RAIL diode_pd2nw_06v0 pj=51.8u area=22.5p
X376 VDD FS_N_GATE FS_N_WELL FS_N_WELL pfet_03v3 ad=6.16p pd=28.88u as=6.16p ps=28.88u w=14u l=0.28u
X377 HS_P_2 HS_PBIAS VDD VDD pfet_03v3 ad=8.8p pd=40.88u as=8.8p ps=40.88u w=20u l=1u
X378 HS_P_8 HS_PBIAS VDD VDD pfet_03v3 ad=8.8p pd=40.88u as=8.8p ps=40.88u w=20u l=1u
X379 ESD_RAIL a_42245_162628# VSS VSS nfet_06v0 ad=13p pd=50.52u as=13p ps=50.52u w=50u l=0.7u
X380 VDD FS_P_GATE FS_P_WELL FS_P_WELL pfet_03v3 ad=6.16p pd=28.88u as=6.16p ps=28.88u w=14u l=0.28u
X381 ESD_RAIL a_42245_162628# VSS VSS nfet_06v0 ad=13p pd=50.52u as=13p ps=50.52u w=50u l=0.7u
X382 ESD_RAIL a_42245_162628# VSS VSS nfet_06v0 ad=13p pd=50.52u as=13p ps=50.52u w=50u l=0.7u
X383 VDD FS_P_GATE FS_P_WELL FS_P_WELL pfet_03v3 ad=6.16p pd=28.88u as=6.16p ps=28.88u w=14u l=0.28u
X384 ESD_RAIL a_44789_189064# a_42245_162628# ESD_RAIL pfet_06v0 ad=1.3p pd=5.52u as=1.3p ps=5.52u w=5u l=0.7u
X385 VDD FS_N_GATE FS_N_WELL FS_N_WELL pfet_03v3 ad=6.16p pd=28.88u as=6.16p ps=28.88u w=14u l=0.28u
X386 VDD FS_P_GATE FS_P_WELL FS_P_WELL pfet_03v3 ad=6.16p pd=28.88u as=6.16p ps=28.88u w=14u l=0.28u
X387 PAD_P DIV_P VSS ppolyf_u_1k r_width=1u r_length=2u
X388 FS_P_OUT PAD_P VSS ppolyf_s r_width=2u r_length=3.5u
X389 VDD FS_N_GATE FS_N_WELL FS_N_WELL pfet_03v3 ad=6.16p pd=28.88u as=6.16p ps=28.88u w=14u l=0.28u
X390 VDD FS_P_GATE FS_P_WELL FS_P_WELL pfet_03v3 ad=6.16p pd=28.88u as=6.16p ps=28.88u w=14u l=0.28u
X391 HS_N_0 HS_PBIAS VDD VDD pfet_03v3 ad=8.8p pd=40.88u as=8.8p ps=40.88u w=20u l=1u
X392 HS_P_0 HS_PBIAS VDD VDD pfet_03v3 ad=8.8p pd=40.88u as=8.8p ps=40.88u w=20u l=1u
X393 a_41005_205505# a_53878_205225# ESD_RAIL ppolyf_u r_width=0.8u r_length=63.855u
X394 a_44789_189064# a_43813_189064# VSS VSS nfet_06v0 ad=1.3p pd=5.52u as=1.3p ps=5.52u w=5u l=0.7u
X395 VDD FS_P_GATE FS_P_WELL FS_P_WELL pfet_03v3 ad=6.16p pd=28.88u as=6.16p ps=28.88u w=14u l=0.28u
X396 TERM_P_R TERM_GATE_P TERM_VCM VSS nfet_03v3 ad=8.8p pd=40.88u as=8.8p ps=40.88u w=20u l=0.28u
X397 PULLUP_P_BLEED_6 PULLUP_P_GATE VSS ppolyf_u_1k r_width=1u r_length=12.5u
X398 VDD FS_N_GATE FS_N_WELL FS_N_WELL pfet_03v3 ad=6.16p pd=28.88u as=6.16p ps=28.88u w=14u l=0.28u
X399 HS_P_2 HS_P PAD_P VSS nfet_06v0 ad=8.8p pd=40.88u as=8.8p ps=40.88u w=20u l=0.7u
X400 VDD FS_P_GATE FS_P_WELL FS_P_WELL pfet_03v3 ad=6.16p pd=28.88u as=6.16p ps=28.88u w=14u l=0.28u
X401 VDD FS_N_GATE FS_N_WELL FS_N_WELL pfet_03v3 ad=6.16p pd=28.88u as=6.16p ps=28.88u w=14u l=0.28u
X402 HS_N_8 HS_PBIAS VDD VDD pfet_03v3 ad=8.8p pd=40.88u as=8.8p ps=40.88u w=20u l=1u
X403 VDD FS_N_GATE FS_N_WELL FS_N_WELL pfet_03v3 ad=6.16p pd=28.88u as=6.16p ps=28.88u w=14u l=0.28u
X404 VDD FS_P_GATE FS_P_WELL FS_P_WELL pfet_03v3 ad=6.16p pd=28.88u as=6.16p ps=28.88u w=14u l=0.28u
X405 VSS a_42245_162628# ESD_RAIL VSS nfet_06v0 ad=13p pd=50.52u as=13p ps=50.52u w=50u l=0.7u
X406 VSS a_42245_162628# ESD_RAIL VSS nfet_06v0 ad=13p pd=50.52u as=13p ps=50.52u w=50u l=0.7u
X407 VSS a_42245_162628# ESD_RAIL VSS nfet_06v0 ad=13p pd=50.52u as=13p ps=50.52u w=50u l=0.7u
X408 VDD PULLUP_P_GATE PULLUP_P_WELL PULLUP_P_WELL pfet_03v3 ad=8.8p pd=40.88u as=8.8p ps=40.88u w=20u l=0.28u
X409 HS_N_10 HS_PBIAS VDD VDD pfet_03v3 ad=8.8p pd=40.88u as=8.8p ps=40.88u w=20u l=1u
X410 TERM_OR_P_B TERM_ENABLE VSS VSS nfet_03v3 ad=0.88p pd=4.88u as=0.88p ps=4.88u w=2u l=0.28u
X411 ESD_RAIL a_42245_162628# VSS VSS nfet_06v0 ad=22p pd=0.10088m as=13p ps=50.52u w=50u l=0.7u
X412 TERM_P_R DIFF_ENABLE TERM_N_R VSS nfet_03v3 ad=8.8p pd=40.88u as=8.8p ps=40.88u w=20u l=0.28u
X413 ESD_RAIL a_53878_206345# ESD_RAIL ppolyf_u r_width=0.8u r_length=63.855u
X414 TERM_OR_N_NS VCM_LOW_OK VSS VSS nfet_03v3 ad=1.76p pd=8.88u as=1.76p ps=8.88u w=4u l=0.28u
X415 TERM_OR_P_NS VCM_LOW_OK VSS VSS nfet_03v3 ad=1.76p pd=8.88u as=1.76p ps=8.88u w=4u l=0.28u
X416 TERM_GATE_P_BLEED_1 TERM_GATE_P_BLEED_2 VSS ppolyf_u_1k r_width=1u r_length=12.5u
X417 PAD_N TERM_N_R VSS ppolyf_s r_width=1u r_length=3.29u
X418 VDD FS_N_GATE FS_N_WELL FS_N_WELL pfet_03v3 ad=6.16p pd=28.88u as=6.16p ps=28.88u w=14u l=0.28u
X419 HS_N_11 HS_N PAD_N VSS nfet_06v0 ad=8.8p pd=40.88u as=8.8p ps=40.88u w=20u l=0.7u
X420 HS_N_0 HS_N PAD_N VSS nfet_06v0 ad=8.8p pd=40.88u as=8.8p ps=40.88u w=20u l=0.7u
X421 PAD_N BYPASS_ENABLE RX_N VSS nfet_06v0 ad=8.8p pd=40.88u as=8.8p ps=40.88u w=20u l=0.7u
X422 VDD FS_P_GATE FS_P_WELL FS_P_WELL pfet_03v3 ad=6.16p pd=28.88u as=6.16p ps=28.88u w=14u l=0.28u
X423 PAD_N BYPASS_ENABLE RX_N VSS nfet_06v0 ad=8.8p pd=40.88u as=8.8p ps=40.88u w=20u l=0.7u
X424 PULLUP_N_BLEED_4 PULLUP_N_BLEED_5 VSS ppolyf_u_1k r_width=1u r_length=12.5u
X425 ESD_RAIL a_42245_162628# VSS VSS nfet_06v0 ad=13p pd=50.52u as=13p ps=50.52u w=50u l=0.7u
C0 PULLUP_P HS_PBIAS 0.31274f
C1 HS_P_13 HS_N_8 0.04828f
C2 HS_N_9 HS_P_6 0.05493f
C3 FS_N_WELL FS_LOW_N 0.87758f
C4 VDD PAD_P 0
C5 PULLUP_P_CONTROL_S HS_N_1 0.03489f
C6 HS_N_8 PAD_P 0.43522f
C7 FS_N_BLEED_1 HS_P 0.09679f
C8 PULLUP_P_BLEED_4 PULLDOWN_N_R 0.05462f
C9 HS_P_9 HS_P_1 0.03494f
C10 TERM_ENABLE TERM_GATE_P_BLEED_1 0.10319f
C11 HS_P_12 HS_N_0 0.07547f
C12 FS_P_OUT HS_N_0 0.5609f
C13 HS_N_0 RX_N 0.00305f
C14 PULLDOWN_P HS_N_0 0.04428f
C15 FS_P_GATE TERM_P_R 0.7299f
C16 DIV_LOW_N FS_LOW_P 0.08856f
C17 FS_P_BLEED_6 HS_N_3 0.06178f
C18 PULLUP_N_OUT PULLDOWN_P_R 0.06256f
C19 HS_N_4 TERM_GATE_N_BLEED_2 0.0525f
C20 TERM_VCM PULLUP_N_BLEED_1 0.04263f
C21 HS_P_10 TERM_OR_P_B 0.09644f
C22 HS_P_13 HS_N_9 0.05493f
C23 HS_N_13 FS_P_WELL 1.9433f
C24 HS_N_11 DIV_LOW_P 0.00184f
C25 HS_P_10 TERM_GATE_P 0.17903f
C26 DIV_LOW_N HS_PBIAS 0.1046f
C27 PULLUP_N_BLEED_4 PULLUP_N 0.24104f
C28 HS_P_7 VCM_LOW_OK 0.03489f
C29 HS_P_7 HS_P_3 0.06116f
C30 HS_P FS_P_BLEED_6 0.06178f
C31 TERM_VCM HS_N_13 0.12019f
C32 HS_N_9 PAD_P 1.20851f
C33 HS_P_5 HS_P_10 0.0481f
C34 FS_P_BLEED_1 HS_PBIAS 0.08856f
C35 HS_P_9 HS_P_6 0.00106f
C36 HS_P_1 TERM_OR_P_B 0.08191f
C37 TERM_P_R HS_P_0 0.07626f
C38 FS_HIGH_N PULLUP_P 0.04377f
C39 HS_P_1 TERM_GATE_P 0.25434f
C40 HS_P_5 HS_P_1 0.02411f
C41 HS_P PULLUP_N_BLEED_4 0.00212f
C42 PULLUP_P_OUT FS_P_WELL 2.91552f
C43 HS_N_4 HS_N_7 0.06976f
C44 PULLUP_P_WELL FS_P_BLEED_6 0.03054f
C45 FS_N_BLEED_4 FS_N_BLEED_2 0.12309f
C46 HS_N_1 TERM_OR_N_S 0.06335f
C47 HS_N_5 TERM_ENABLE 0.04808f
C48 PULLUP_P_OUT TERM_VCM 0.39727f
C49 PULLUP_N_WELL PULLUP_N_BLEED_1 0.08208f
C50 HS_N PULLUP_N_BLEED_2 0.12943f
C51 HS_N PULLUP_P_GATE 0.16609f
C52 VDD FS_P_GATE 25.9057f
C53 PULLUP_P_CONTROL_S HS_N_2 0.03489f
C54 FS_N_GATE FS_N_CONTROL_S 3.06729f
C55 FS_P_GATE HS_N_8 1.02357f
C56 HS_N_11 HS_N_10 0.13701p
C57 HS_N_12 FS_P_WELL 1.95995f
C58 PULLDOWN_P_R TERM_GATE_P_BLEED_1 0.01413f
C59 HS_N_12 TERM_VCM 0.12019f
C60 PULLUP_P PULLDOWN_N 0.06103f
C61 PULLDOWN_P PULLUP_N_BLEED_5 0.0032f
C62 HS_P_13 HS_P_9 0.04877f
C63 HS_P_6 TERM_OR_P_B 0.10133f
C64 PULLUP_P_BLEED_2 PULLUP_P_BLEED_3 2.29663f
C65 FS_N_WELL PULLDOWN_N_R 2.26226f
C66 HS_N DIV_N 0.04977f
C67 FS_P_OUT DIV_LOW_P 0.13605f
C68 PULLUP_N_OUT FS_N_BLEED_4 0.10124f
C69 FS_P_BLEED_0 FS_P_BLEED_1 7.1724f
C70 HS_P_0 TERM_OR_P_NS 0.07621f
C71 HS_N HS_P_11 0.6688f
C72 PULLUP_N_OUT HS_N_1 0.05062f
C73 HS_P_9 PAD_P 1.35439f
C74 HS_N_1 TERM_GATE_N 0.05206f
C75 HS_P_6 TERM_GATE_P 0.15508f
C76 HS_N HS_P_4 0.15877f
C77 FS_P_CONTROL_S HS_PBIAS 0.04861f
C78 HS_P_5 HS_P_6 32.3343f
C79 FS_N_BLEED_1 FS_LOW_P 0.23767f
C80 PULLUP_N_BLEED_6 PULLDOWN_N 0.00832f
C81 DIV_N PULLUP_P_GATE 0.00135f
C82 VDD HS_P_0 3.95338f
C83 HS_N_8 HS_P_0 0.03523f
C84 HS_N_4 PAD_N 1.29614f
C85 HS_P_7 TERM_GATE_P_BLEED_0 0.02404f
C86 HS_N_9 FS_P_GATE 1.02792f
C87 PULLUP_N_GATE TERM_P_R 0.17963f
C88 FS_N_BLEED_1 HS_PBIAS 0.07798f
C89 TERM_ENABLE PULLDOWN_P_R 0.04377f
C90 HS_P_13 TERM_OR_P_B 0.10389f
C91 HS_P_12 HS_N_10 0.07709f
C92 PULLUP_P_BLEED_4 TERM_VCM 0.03472f
C93 HS_P_13 TERM_GATE_P 0.15775f
C94 HS_P_11 HS_P_4 0
C95 FS_P_OUT HS_N_10 0.44249f
C96 HS_P_13 HS_P_5 0.26928f
C97 HS_N_5 PULLDOWN_P_R 0.02404f
C98 BYPASS_ENABLE TERM_GATE_N_BLEED_1 0.00766f
C99 TERM_OR_N_S HS_N_2 0.06335f
C100 HS_P_5 PAD_P 1.15443f
C101 FS_P_BLEED_0 FS_P_CONTROL_S 0.04299f
C102 PULLUP_P_WELL PULLUP_P_BLEED_2 0.12013f
C103 FS_N_BLEED_2 FS_N_BLEED_0 0.11777f
C104 HS_N_9 HS_P_0 0.03791f
C105 VCM_LOW_OK TERM_OR_P_S 1.87902f
C106 BYPASS_ENABLE DIFF_ENABLE 6.50064f
C107 HS_P_8 TERM_P_R 0.08296f
C108 FS_P_BLEED_6 HS_PBIAS 0.08856f
C109 TERM_P_R HS_N_7 0.0959f
C110 VDD PULLUP_N_GATE 12.2975f
C111 TERM_GATE_N HS_N_2 0.0506f
C112 FS_HIGH_N FS_N_BLEED_1 0
C113 FS_N_BLEED_4 TERM_ENABLE 0.08954f
C114 TERM_GATE_N_BLEED_2 HS_N_8 0.0525f
C115 PULLUP_N_BLEED_4 HS_PBIAS 0.01633f
C116 PULLUP_N_OUT DIV_ENABLE 0.05062f
C117 TERM_GATE_N_BLEED_1 FS_HIGH_P 0.15807f
C118 HS_N_1 TERM_ENABLE 0.10607f
C119 HS_N FS_P_BLEED_3 0.01431f
C120 TERM_GATE_N DIV_ENABLE 0.1284f
C121 FS_LOW_N TERM_OR_N_S 0.5416f
C122 HS_P_8 TERM_OR_P_NS 0.02846f
C123 FS_LOW_N FS_N_BLEED_2 0
C124 ESD_RAIL PAD_N 22.0614f
C125 FS_HIGH_P DIFF_ENABLE 0.1992f
C126 TERM_N_R HS_N_0 0.12127f
C127 HS_N_7 TERM_OR_P_NS 0.00491f
C128 FS_N_WELL TERM_VCM 1.81814f
C129 HS_N FS_N_OUT 1.22169f
C130 FS_P_BLEED_3 PULLUP_P_GATE 0
C131 HS_N_6 HS_N_0 0.03911f
C132 VDD HS_P_8 4.99906f
C133 HS_N_1 HS_N_5 0.04302f
C134 HS_P_8 HS_N_8 0.09066f
C135 HS_N_11 FS_N_GATE 0.01488f
C136 PULLUP_P_CONTROL_S PULLDOWN_N_R 0.05462f
C137 VDD HS_N_7 6.97232f
C138 PULLUP_N_OUT FS_LOW_N 0.06426f
C139 HS_N_9 TERM_GATE_N_BLEED_2 0.0525f
C140 HS_N_8 HS_N_7 0.11905p
C141 FS_N_OUT PULLUP_P_GATE 0.05082f
C142 FS_LOW_N TERM_GATE_N 0.09035f
C143 DIV_N FS_P_BLEED_3 0
C144 PULLUP_P_BLEED_5 HS_N_13 0.0525f
C145 HS_N_11 VCM_LOW_OK 0.03489f
C146 HS_N_11 HS_P_3 0.02508f
C147 FS_N_WELL FS_N_BLEED_6 0.00637f
C148 HS_P_0 TERM_OR_P_B 0.09384f
C149 PULLUP_P_BLEED_6 HS_N_7 0.03663f
C150 DIV_N FS_N_OUT 0.07748f
C151 TERM_GATE_P HS_P_0 0.25837f
C152 HS_P_8 HS_N_9 0.10431f
C153 HS_N_1 PULLDOWN_P_R 0.02445f
C154 HS_P_5 HS_P_0 0.00297f
C155 HS_N_4 FS_P_BLEED_5 0.06178f
C156 TERM_ENABLE HS_N_2 0.04808f
C157 HS_N_9 HS_N_7 0.04151f
C158 VDD PAD_N 0.00457f
C159 FS_P_BLEED_4 HS_N_0 0.02973f
C160 PULLDOWN_P FS_N_GATE 1.27435f
C161 HS_N_8 PAD_N 1.07245f
C162 PULLUP_N_BLEED_4 PULLDOWN_N 0.00763f
C163 TERM_ENABLE DIV_ENABLE 0.03192f
C164 HS_N_5 HS_N_2 0.00106f
C165 TERM_OR_N_S PULLDOWN_N_R 0.12757f
C166 PULLUP_P_BLEED_5 HS_N_12 0.05263f
C167 FS_N_BLEED_2 PULLDOWN_N_R 0.05188f
C168 HS_P_12 HS_P_3 0.02899f
C169 HS_N_13 FS_P_BLEED_2 0.03472f
C170 HS_P_12 VCM_LOW_OK 0.03489f
C171 ESD_RAIL a_53878_206345# 0.5677f
C172 FS_P_OUT HS_P_3 0.09146f
C173 PULLUP_N_GATE FS_N_BLEED_5 0
C174 FS_P_OUT VCM_LOW_OK 0.37711f
C175 HS_P_8 HS_P_9 30.3927f
C176 PULLDOWN_P VCM_LOW_OK 0.03743f
C177 TERM_GATE_N_BLEED_1 TERM_OR_N_B 0
C178 PULLUP_N_OUT PULLDOWN_N_R 0.12053f
C179 HS_N_5 DIV_ENABLE 0.03089f
C180 HS_N_11 FS_HIGH_P 0
C181 PAD_P RX_P 8.52519f
C182 HS_N_9 PAD_N 1.0992f
C183 TERM_GATE_N PULLDOWN_N_R 0.15401f
C184 FS_LOW_N TERM_ENABLE 0.2377f
C185 PULLUP_P_OUT FS_P_BLEED_2 0.05902f
C186 BYPASS_ENABLE RX_N 7.14256f
C187 TERM_N_R HS_N_10 0.06034f
C188 HS_N_0 HS_N_3 0.07842f
C189 HS_N_6 HS_N_10 0
C190 PULLUP_P_BLEED_4 PULLUP_P_BLEED_5 6.36804f
C191 HS_N_12 FS_P_BLEED_2 0.03472f
C192 PULLUP_P_CONTROL_S TERM_VCM 0.03425f
C193 FS_LOW_N HS_N_5 0.04574f
C194 HS_N_2 PULLDOWN_P_R 0.02404f
C195 HS_N HS_P_7 0.15132f
C196 FS_N_OUT FS_P_BLEED_3 0.13926f
C197 FS_P_GATE FS_P_BLEED_1 0.16375f
C198 HS_P_8 TERM_OR_P_B 0.10057f
C199 HS_P HS_N_0 0.16181f
C200 HS_N_7 TERM_OR_P_B 0.07211f
C201 HS_P_8 TERM_GATE_P 0.15508f
C202 HS_P_8 HS_P_5 0.00106f
C203 HS_P_12 TERM_GATE_P_BLEED_0 0.03636f
C204 TERM_GATE_P_BLEED_1 PULLDOWN_N_R 0.00195f
C205 HS_N_7 TERM_GATE_P 0.12198f
C206 FS_P_OUT FS_HIGH_P 0.09741f
C207 HS_P_9 PAD_N 6.47937f
C208 HS_N_0 PULLUP_P_WELL 0.38231f
C209 HS_N_4 HS_N_13 0.14463f
C210 HS_P_5 HS_N_7 0.03489f
C211 HS_P_11 HS_P_7 0.0963f
C212 DIV_P TERM_P_R 0.02242f
C213 TERM_P_R TERM_GATE_P_BLEED_2 0.06551f
C214 FS_LOW_N PULLDOWN_P_R 0.00864f
C215 PULLUP_N PULLUP_N_BLEED_5 0.08999f
C216 HS_P_7 HS_P_4 0.06067f
C217 FS_P_BLEED_4 HS_N_10 0.02915f
C218 PULLUP_P PULLUP_N_GATE 1.41779f
C219 HS_N_4 PULLUP_P_OUT 0.02404f
C220 FS_P_GATE FS_P_CONTROL_S 1.43654f
C221 HS_N FS_N_CONTROL_S 0.11872f
C222 TERM_ENABLE PULLDOWN_N_R 0.13638f
C223 PULLUP_P TERM_GATE_N_BLEED_2 0.09196f
C224 TERM_OR_N_S TERM_VCM 0
C225 PULLUP_N_BLEED_3 PULLDOWN_N_R 0.07928f
C226 HS_N_1 HS_N_2 0.11091f
C227 FS_N_BLEED_4 FS_N_BLEED_0 0.12212f
C228 a_41005_205505# a_41005_204945# 0.0346f
C229 PULLUP_N_GATE PULLUP_N_BLEED_6 3.03119f
C230 TERM_GATE_N_BLEED_0 VCM_LOW_OK 0.08402f
C231 HS_N_4 HS_N_12 0
C232 VDD FS_P_BLEED_5 0.00257f
C233 HS_P_5 PAD_N 1.55482f
C234 HS_N_11 TERM_OR_N_B 0.02978f
C235 RX_P HS_P_0 0
C236 PULLUP_N_OUT FS_P_WELL 2.56506f
C237 HS_N_8 FS_P_BLEED_5 0.06266f
C238 HS_N_1 DIV_ENABLE 0.03528f
C239 HS_N TERM_GATE_N_BLEED_1 0.04828f
C240 HS_N_5 PULLDOWN_N_R 0.06159f
C241 VDD TERM_GATE_P_BLEED_2 0.084f
C242 PULLUP_N_OUT TERM_VCM 0.50736f
C243 VDD DIV_P 0.11168f
C244 HS_N DIFF_ENABLE 0.22317f
C245 TERM_GATE_N TERM_VCM 26.4092f
C246 PULLUP_P HS_N_7 0.05062f
C247 FS_N_BLEED_2 FS_N_BLEED_6 0.00763f
C248 HS_N_10 HS_N_3 0.07409f
C249 FS_N_BLEED_2 PULLUP_N_WELL 0
C250 FS_LOW_N FS_N_BLEED_4 0
C251 HS_N_0 FS_LOW_P 0.08516f
C252 TERM_N_R FS_N_GATE 0.81764f
C253 FS_LOW_N HS_N_1 0.04626f
C254 PULLUP_P_BLEED_4 HS_N_4 0.03489f
C255 DIV_N TERM_GATE_N_BLEED_1 0.10151f
C256 FS_P_GATE FS_P_BLEED_6 5.18505f
C257 PULLUP_N_OUT FS_N_BLEED_6 0.05445f
C258 TERM_P_R PULLUP_N_BLEED_1 0.04766f
C259 HS_N_0 HS_PBIAS 5.90003f
C260 HS_P HS_N_10 0.20736f
C261 HS_N_9 FS_P_BLEED_5 0.06295f
C262 PULLUP_N_OUT PULLUP_N_WELL 32.5189f
C263 TERM_N_R VCM_LOW_OK 0.14699f
C264 PULLDOWN_P TERM_OR_N_B 0.08713f
C265 PULLDOWN_P_R PULLDOWN_N_R 33.0605f
C266 TERM_N_R HS_P_3 0.05037f
C267 TERM_P_R HS_N_13 0.05952f
C268 DIV_LOW_N HS_N_7 0.06178f
C269 HS_N_10 PULLUP_P_WELL 0.2167f
C270 TERM_OR_N_NS TERM_N_R 0.00361f
C271 FS_P_BLEED_1 HS_N_7 0.06178f
C272 HS_N_6 VCM_LOW_OK 0.03549f
C273 HS_N_6 HS_P_3 0.03089f
C274 BYPASS_ENABLE TERM_N_R 0.00444f
C275 PULLUP_P_OUT TERM_P_R 0.30489f
C276 HS_N_2 DIV_ENABLE 0.03089f
C277 DIV_ENABLE FS_N_BLEED_0 0
C278 a_41005_203545# a_41005_203825# 0.03725f
C279 FS_P_BLEED_0 HS_N_0 0.06178f
C280 VDD PULLUP_N_BLEED_1 0.45607f
C281 FS_N_BLEED_3 FS_N_WELL 0
C282 TERM_ENABLE FS_P_WELL 2.37092f
C283 HS_N_12 TERM_P_R 0.0597f
C284 FS_LOW_P DIV_LOW_P 0.12545f
C285 TERM_ENABLE TERM_VCM 0.52207f
C286 VDD HS_N_13 6.76594f
C287 FS_LOW_N HS_N_2 0.08747f
C288 FS_LOW_N FS_N_BLEED_0 0.08493f
C289 HS_N_8 HS_N_13 0.05624f
C290 HS_PBIAS DIV_LOW_P 0
C291 PULLUP_P_OUT TERM_OR_P_NS 0.1011f
C292 TERM_N_R FS_HIGH_P 0.09473f
C293 HS_N HS_N_11 5.51295f
C294 PULLUP_P_BLEED_4 PULLUP_P_BLEED_1 0.0078f
C295 HS_N_5 FS_P_WELL 1.92307f
C296 FS_N_BLEED_4 PULLDOWN_N_R 0.08856f
C297 FS_P_CONTROL_S HS_N_7 0.03226f
C298 HS_N_1 PULLDOWN_N_R 0.06832f
C299 HS_N_5 TERM_VCM 0.12753f
C300 PULLUP_P_BLEED_6 HS_N_13 0.02404f
C301 TERM_N_R TERM_GATE_P_BLEED_0 0.14463f
C302 VDD PULLUP_P_OUT 4.00763f
C303 FS_LOW_N DIV_ENABLE 0.0351f
C304 PULLUP_P_OUT HS_N_8 0.02404f
C305 FS_N_OUT FS_N_CONTROL_S 0.04187f
C306 TERM_ENABLE FS_N_BLEED_6 0.06151f
C307 HS_N_11 PULLUP_P_GATE 0.07363f
C308 TERM_ENABLE PULLUP_N_WELL 0.54844f
C309 DIV_P TERM_OR_P_B 0.0223f
C310 HS_N_6 TERM_GATE_P_BLEED_0 0
C311 PULLUP_P_BLEED_4 TERM_P_R 0.04766f
C312 TERM_GATE_P_BLEED_2 TERM_OR_P_B 0.00349f
C313 HS_N_9 HS_N_13 0.15155f
C314 HS_N_10 FS_LOW_P 0.08505f
C315 PULLUP_N_WELL PULLUP_N_BLEED_3 0.002f
C316 VDD HS_N_12 6.63143f
C317 a_41005_205505# m2_42279_196800# 0
C318 DIV_N HS_N_11 0.03311f
C319 DIV_P TERM_GATE_P 0.02274f
C320 HS_N_12 HS_N_8 0
C321 FS_N_OUT TERM_GATE_N_BLEED_1 0.06167f
C322 TERM_GATE_P TERM_GATE_P_BLEED_2 0.40344f
C323 HS_P_11 HS_N_11 0.06806f
C324 HS_N_10 HS_PBIAS 1.07528f
C325 PAD_N RX_P 1.67336f
C326 PULLUP_N_GATE PULLUP_N_BLEED_4 0.10387f
C327 PULLUP_P_BLEED_3 VCM_LOW_OK 0.15602f
C328 HS_P_2 HS_P_3 34.3283f
C329 TERM_GATE_N_BLEED_0 TERM_OR_N_B 0.00477f
C330 HS_N HS_P_12 0.5567f
C331 VCM_LOW_OK HS_P_2 0.03489f
C332 PULLDOWN_P_R FS_P_WELL 3.17324f
C333 HS_N_9 PULLUP_P_OUT 0.02404f
C334 HS_N FS_P_OUT 20.4712f
C335 PULLUP_P_BLEED_6 HS_N_12 0.02427f
C336 PULLDOWN_P_R TERM_VCM 0.22328f
C337 HS_P FS_N_GATE 1.4888f
C338 PULLUP_P_BLEED_0 PULLUP_P_GATE 0.05117f
C339 a_41005_203825# m2_42279_196800# 0
C340 HS_N_3 HS_P_3 0.03733f
C341 PULLUP_P_BLEED_5 TERM_OR_N_S 0.00257f
C342 FS_P_BLEED_6 HS_N_7 0.06178f
C343 VCM_LOW_OK HS_N_3 0.03489f
C344 PULLDOWN_P PULLUP_N_BLEED_2 0.06517f
C345 PULLDOWN_P PULLUP_P_GATE 0.03883f
C346 PULLUP_P_BLEED_4 VDD 0.44664f
C347 HS_N_9 HS_N_12 0.03489f
C348 PULLUP_P_BLEED_4 HS_N_8 0.03489f
C349 PULLDOWN_N PULLUP_N_BLEED_5 0.0078f
C350 HS_P_12 DIV_N 0.01246f
C351 HS_P VCM_LOW_OK 0.04312f
C352 HS_P HS_P_3 1.89056f
C353 HS_N_2 PULLDOWN_N_R 0.02404f
C354 a_41005_203545# a_41005_204945# 0
C355 HS_P_11 HS_P_12 46.9655f
C356 FS_P_OUT DIV_N 0.05123f
C357 DIV_N RX_N 1.36638f
C358 FS_P_BLEED_0 HS_N_10 0.06178f
C359 PULLUP_N_OUT PULLUP_P_BLEED_5 0.09196f
C360 HS_P_12 HS_P_4 0
C361 PULLDOWN_P DIV_N 0.04613f
C362 PULLUP_P_BLEED_6 PULLUP_P_BLEED_4 0.00153f
C363 FS_N_WELL TERM_P_R 1.49004f
C364 HS_N_0 HS_P_6 0.06114f
C365 DIV_ENABLE PULLDOWN_N_R 0.04455f
C366 PULLUP_P_OUT HS_P_9 0.06897f
C367 PULLUP_P_WELL VCM_LOW_OK 0.31926f
C368 TERM_N_R TERM_OR_N_B 5.99904f
C369 HS_N_13 TERM_OR_P_B 0.07271f
C370 PULLUP_P_BLEED_4 HS_N_9 0.03489f
C371 HS_N_1 FS_P_WELL 2.0562f
C372 HS_N_1 TERM_VCM 0.16434f
C373 FS_N_BLEED_4 TERM_VCM 0.02041f
C374 TERM_GATE_P_BLEED_0 HS_P_2 0.02483f
C375 HS_N_6 TERM_OR_N_B 0.02846f
C376 BYPASS_ENABLE PULLUP_P_WELL 0.00823f
C377 PULLUP_P_CONTROL_S HS_N_4 0.03489f
C378 FS_LOW_N PULLDOWN_N_R 0.05913f
C379 PULLUP_N_BLEED_0 PULLUP_N_BLEED_2 0
C380 HS_N_13 TERM_GATE_P 0.1076f
C381 PULLUP_N_OUT FS_P_BLEED_2 0.06151f
C382 FS_P_BLEED_3 HS_N_11 0
C383 HS_P_13 HS_N_0 0.02661f
C384 HS_P_5 HS_N_13 0.03489f
C385 PULLUP_P_OUT TERM_OR_P_B 0.19951f
C386 HS_N_0 PAD_P 0.14558f
C387 FS_N_OUT HS_N_11 0.00528f
C388 VDD FS_N_WELL 0.10537p
C389 FS_N_BLEED_4 FS_N_BLEED_6 0.00855f
C390 HS_P TERM_GATE_P_BLEED_0 0.00154f
C391 PULLUP_P_OUT TERM_GATE_P 0.40537f
C392 HS_N_10 HS_P_10 0.09288f
C393 FS_N_BLEED_4 PULLUP_N_WELL 0
C394 HS_N_12 TERM_OR_P_B 0.07307f
C395 FS_LOW_P FS_N_GATE 0.44654f
C396 PULLUP_P_WELL FS_HIGH_P 0.27585f
C397 FS_N_BLEED_3 FS_N_BLEED_2 4.62519f
C398 HS_N_12 TERM_GATE_P 0.10814f
C399 FS_N_GATE HS_PBIAS 2.61795f
C400 HS_N_12 HS_P_5 0.03489f
C401 a_41005_204945# m2_42279_196800# 0
C402 PULLUP_P_BLEED_5 TERM_ENABLE 0
C403 FS_LOW_P HS_P_3 0.04607f
C404 FS_P_OUT FS_P_BLEED_3 0
C405 PULLUP_P PULLUP_N_BLEED_1 0.05744f
C406 FS_LOW_P VCM_LOW_OK 0.22718f
C407 HS_N_2 FS_P_WELL 1.91814f
C408 HS_N_4 TERM_OR_N_S 0.06531f
C409 FS_N_BLEED_3 PULLUP_N_OUT 0.05216f
C410 HS_PBIAS HS_P_3 6.23881f
C411 HS_P_12 FS_N_OUT 0.12335f
C412 a_53878_205225# a_53878_205785# 0.0346f
C413 HS_N_2 TERM_VCM 0.12324f
C414 DIV_P RX_P 1.39534f
C415 HS_PBIAS VCM_LOW_OK 0.40495f
C416 FS_P_OUT FS_N_OUT 1.00178f
C417 FS_N_OUT RX_N 0.01566f
C418 PULLUP_P_BLEED_5 HS_N_5 0.0525f
C419 PULLUP_P HS_N_13 0.04377f
C420 PULLUP_P_BLEED_1 PULLUP_P_CONTROL_S 0
C421 PULLDOWN_P FS_N_OUT 0.59758f
C422 PULLUP_N_OUT HS_N_4 0.00298f
C423 FS_P_GATE HS_N_0 1.00578f
C424 DIV_ENABLE FS_P_WELL 0.08405f
C425 HS_N_10 HS_P_6 0.0597f
C426 TERM_VCM DIV_ENABLE 0.2249f
C427 HS_N_4 TERM_GATE_N 0.04808f
C428 PULLUP_P_CONTROL_S TERM_P_R 0.04719f
C429 TERM_ENABLE FS_P_BLEED_2 0.05902f
C430 PULLUP_P PULLUP_P_OUT 0.00546f
C431 HS_N TERM_N_R 0.27948f
C432 FS_N_BLEED_0 FS_N_BLEED_6 0.00763f
C433 FS_HIGH_N FS_N_GATE 5.97448f
C434 TERM_OR_N_B HS_N_3 0.02846f
C435 FS_N_BLEED_0 PULLUP_N_WELL 0
C436 FS_P_BLEED_0 VCM_LOW_OK 0.01461f
C437 PULLUP_P HS_N_12 0
C438 FS_LOW_N TERM_VCM 0.12878f
C439 a_41005_203545# m2_42279_196800# 0.05457f
C440 HS_N HS_N_6 7.99416f
C441 DIV_LOW_N HS_N_13 0.06178f
C442 DIV_ENABLE FS_N_BLEED_6 0.03564f
C443 HS_N_0 HS_P_0 0.04061f
C444 FS_LOW_P FS_HIGH_P 8.66124f
C445 HS_N_5 FS_P_BLEED_2 0.03472f
C446 TERM_N_R PULLUP_P_GATE 0.20833f
C447 PULLUP_P_BLEED_5 PULLDOWN_P_R 0.09204f
C448 HS_P_13 HS_N_10 0.0252f
C449 FS_P_BLEED_1 HS_N_13 0.06178f
C450 HS_N_6 PULLUP_P_GATE 0.07429f
C451 DIV_ENABLE PULLUP_N_WELL 0.02583f
C452 HS_P TERM_OR_N_B 0.02904f
C453 FS_P_BLEED_6 FS_P_BLEED_5 3.5401f
C454 HS_N_10 PAD_P 0.11949f
C455 FS_HIGH_P HS_PBIAS 0.03865f
C456 DIV_N TERM_N_R 0.19787f
C457 HS_P_11 TERM_N_R 0.05722f
C458 FS_N_WELL FS_N_BLEED_5 0
C459 HS_P_11 HS_N_6 0.03089f
C460 TERM_N_R HS_P_4 0.05722f
C461 HS_N_6 DIV_N 0.03311f
C462 PULLUP_P_OUT FS_P_BLEED_1 0.11038f
C463 VDD PULLUP_P_CONTROL_S 7.26698f
C464 FS_LOW_N FS_N_BLEED_6 0.07134f
C465 FS_HIGH_N BYPASS_ENABLE 0
C466 PULLUP_P_CONTROL_S HS_N_8 0.03489f
C467 FS_N_BLEED_3 TERM_ENABLE 0.01168f
C468 DIV_LOW_N HS_N_12 0.06178f
C469 PULLUP_P_BLEED_4 PULLUP_P 0.22457f
C470 HS_N_6 HS_P_4 0.03738f
C471 FS_LOW_N PULLUP_N_WELL 0.13755f
C472 TERM_P_R TERM_OR_N_S 0.30551f
C473 HS_N_12 FS_P_BLEED_1 0.06178f
C474 PULLUP_P_BLEED_1 PULLUP_N_OUT 0.04643f
C475 PULLDOWN_P_R FS_P_BLEED_2 0.05445f
C476 HS_N FS_P_BLEED_4 0.0463f
C477 HS_N_4 TERM_ENABLE 0.04808f
C478 FS_P_CONTROL_S HS_N_13 0.03226f
C479 FS_P_BLEED_0 FS_HIGH_P 0.01425f
C480 HS_P_10 HS_P_3 0.02866f
C481 HS_P_10 VCM_LOW_OK 0.09044f
C482 FS_P_BLEED_4 PULLUP_P_GATE 0
C483 HS_N_9 PULLUP_P_CONTROL_S 0.03489f
C484 PULLUP_N_OUT TERM_P_R 0.26239f
C485 FS_HIGH_N FS_HIGH_P 30.5739f
C486 HS_N_1 PULLUP_P_BLEED_5 0.05286f
C487 TERM_P_R TERM_GATE_N 0.14873f
C488 HS_P_7 HS_P_12 0.11376f
C489 TERM_GATE_N_BLEED_2 HS_N_0 0.05293f
C490 FS_P_GATE HS_N_10 1.01709f
C491 HS_P_1 HS_P_3 0.06154f
C492 HS_N_4 HS_N_5 0.12189p
C493 PULLDOWN_N_R FS_P_WELL 2.75107f
C494 HS_P_1 VCM_LOW_OK 0.03489f
C495 TERM_VCM PULLDOWN_N_R 0.35898f
C496 HS_N HS_P_2 0.46352f
C497 VDD TERM_OR_N_S 13.5629f
C498 HS_N_8 TERM_OR_N_S 0.07039f
C499 PULLUP_N_OUT TERM_OR_P_NS 0.11021f
C500 HS_N_12 FS_P_CONTROL_S 0.03226f
C501 PULLUP_P_GATE PULLUP_P_BLEED_3 0.18954f
C502 HS_N HS_N_3 2.50774f
C503 HS_N_0 HS_N_7 0.07113f
C504 PULLUP_P_BLEED_6 TERM_OR_N_S 0.00257f
C505 HS_N_10 HS_P_0 0.06989f
C506 PULLDOWN_N_R FS_N_BLEED_6 0.04811f
C507 TERM_GATE_N_BLEED_1 HS_N_11 0.03489f
C508 PULLUP_N PULLUP_N_BLEED_2 0.2265f
C509 PULLUP_P FS_N_WELL 1.96677f
C510 VDD PULLUP_N_OUT 5.35116f
C511 FS_P_BLEED_6 HS_N_13 0.06178f
C512 HS_N_1 FS_P_BLEED_2 0.03472f
C513 HS_P_6 HS_P_3 0.07261f
C514 HS_PBIAS TERM_OR_N_B 0.05921f
C515 VDD TERM_GATE_N 5.37222f
C516 PULLUP_N_OUT HS_N_8 0.06129f
C517 TERM_P_R TERM_GATE_P_BLEED_1 0.00257f
C518 PULLUP_N_WELL PULLDOWN_N_R 0.3205f
C519 PULLUP_P_GATE HS_N_3 0.07211f
C520 PULLUP_N_BLEED_4 PULLUP_N_BLEED_1 0
C521 HS_N HS_P 2.27647f
C522 HS_P_11 HS_P_2 0.00106f
C523 HS_N_8 TERM_GATE_N 0.05386f
C524 HS_P_6 VCM_LOW_OK 0.03489f
C525 HS_N_4 PULLDOWN_P_R 0.02404f
C526 FS_N_OUT TERM_N_R 0.43893f
C527 PULLUP_N_GATE PULLUP_N_BLEED_5 0.26272f
C528 HS_N_9 TERM_OR_N_S 0.07337f
C529 HS_P_4 HS_P_2 0.03986f
C530 HS_P_10 TERM_GATE_P_BLEED_0 0.03777f
C531 HS_P PULLUP_N_BLEED_2 0.07928f
C532 DIV_N HS_N_3 0.03354f
C533 PULLUP_P_OUT FS_P_BLEED_6 0.05127f
C534 HS_P PULLUP_P_GATE 0.0794f
C535 PULLUP_P_BLEED_6 PULLUP_N_OUT 0.09196f
C536 PULLUP_P_BLEED_1 TERM_ENABLE 0.00606f
C537 PULLUP_P_BLEED_5 HS_N_2 0.0525f
C538 HS_N PULLUP_P_WELL 0.4257f
C539 PULLDOWN_P FS_N_CONTROL_S 0.09193f
C540 a_53878_204665# a_53878_205225# 0.0346f
C541 HS_P_1 TERM_GATE_P_BLEED_0 0.05525f
C542 HS_P_13 HS_P_3 0.2651f
C543 HS_P_13 VCM_LOW_OK 0.03489f
C544 HS_P DIV_N 0.03581f
C545 HS_N_12 FS_P_BLEED_6 0.06178f
C546 HS_N_9 PULLUP_N_OUT 0.01492f
C547 TERM_P_R TERM_ENABLE 0.54261f
C548 HS_N_0 PAD_N 1.42664f
C549 HS_P_11 HS_P 5.65023f
C550 PULLUP_P_BLEED_5 DIV_ENABLE 0
C551 TERM_P_R PULLUP_N_BLEED_3 0.00257f
C552 HS_N_9 TERM_GATE_N 0.05603f
C553 PULLUP_P_WELL PULLUP_P_GATE 35.8752f
C554 PAD_P VCM_LOW_OK 0.00476f
C555 HS_P HS_P_4 1.7567f
C556 PAD_P HS_P_3 1.68578f
C557 PULLDOWN_P TERM_GATE_N_BLEED_1 0.04828f
C558 VDD TERM_GATE_P_BLEED_1 0.07121f
C559 FS_N_BLEED_3 FS_N_BLEED_4 6.17691f
C560 PULLDOWN_P DIFF_ENABLE 0.11011f
C561 TERM_P_R HS_N_5 0.05893f
C562 FS_P_BLEED_4 FS_P_BLEED_3 0.46081f
C563 DIV_N PULLUP_P_WELL 0.08038f
C564 BYPASS_ENABLE PAD_P 8.2284f
C565 HS_N_2 FS_P_BLEED_2 0.03472f
C566 FS_LOW_N PULLUP_P_BLEED_5 0.08298f
C567 TERM_GATE_N_BLEED_2 HS_N_10 0.0527f
C568 HS_P_6 TERM_GATE_P_BLEED_0 0.02404f
C569 TERM_ENABLE TERM_OR_P_NS 0.1642f
C570 HS_N_4 HS_N_1 0.04305f
C571 TERM_VCM FS_P_WELL 1.39031f
C572 FS_P_BLEED_4 FS_N_OUT 0.06639f
C573 PULLUP_N_OUT HS_P_9 0.07928f
C574 PULLUP_P_BLEED_1 PULLDOWN_P_R 0.01413f
C575 VDD TERM_ENABLE 14.695f
C576 DIV_ENABLE FS_P_BLEED_2 0.01375f
C577 FS_N_BLEED_5 FS_N_BLEED_2 0.10559f
C578 HS_N_8 TERM_ENABLE 0.10575f
C579 HS_N_5 TERM_OR_P_NS 0.00258f
C580 HS_N_10 HS_N_7 0.03027f
C581 HS_N FS_LOW_P 0.10015f
C582 HS_P_13 TERM_GATE_P_BLEED_0 0.0256f
C583 TERM_VCM FS_N_BLEED_6 0.04263f
C584 TERM_P_R PULLDOWN_P_R 0.16322f
C585 PULLUP_P_BLEED_6 TERM_ENABLE 0
C586 VDD HS_N_5 6.45763f
C587 HS_N_8 HS_N_5 0.04894f
C588 PULLUP_N_OUT FS_N_BLEED_5 0.10124f
C589 HS_N HS_PBIAS 0.39671f
C590 FS_N_WELL FS_N_BLEED_1 0.00262f
C591 FS_P_GATE VCM_LOW_OK 1.11181f
C592 PULLUP_P PULLUP_P_CONTROL_S 3.928f
C593 TERM_VCM PULLUP_N_WELL 0.30585f
C594 FS_LOW_P PULLUP_N_BLEED_2 0.05872f
C595 FS_LOW_P PULLUP_P_GATE 0.06878f
C596 PULLUP_N_OUT TERM_OR_P_B 0.20772f
C597 ESD_RAIL a_53878_203545# 0.56772f
C598 PULLUP_N_BLEED_2 HS_PBIAS 0.07928f
C599 HS_N_9 TERM_ENABLE 0.04808f
C600 FS_N_BLEED_3 FS_N_BLEED_0 0.1187f
C601 FS_N_OUT HS_N_3 0.06167f
C602 PULLUP_P_BLEED_6 HS_N_5 0.03069f
C603 PULLUP_P_GATE HS_PBIAS 0.16217f
C604 PULLUP_N_OUT TERM_GATE_P 0.37427f
C605 HS_P_11 FS_LOW_P 0.05239f
C606 DIV_N FS_LOW_P 6.00722f
C607 PULLDOWN_P_R TERM_OR_P_NS 0.05654f
C608 PULLUP_N_OUT HS_P_5 0.02859f
C609 HS_P_0 HS_P_3 0.03772f
C610 HS_P FS_N_OUT 0.76324f
C611 PULLUP_N_WELL FS_N_BLEED_6 0.02164f
C612 HS_P_12 HS_N_11 0.06914f
C613 HS_P_11 HS_PBIAS 9.38284f
C614 HS_N_9 HS_N_5 0.04079f
C615 HS_N_10 PAD_N 1.35483f
C616 VCM_LOW_OK HS_P_0 0.04122f
C617 DIV_N HS_PBIAS 0.13901f
C618 FS_LOW_P HS_P_4 0.04599f
C619 HS_N_4 HS_N_2 0.00206f
C620 TERM_GATE_N_BLEED_1 TERM_GATE_N_BLEED_0 2.88199f
C621 FS_P_OUT HS_N_11 0.43976f
C622 VDD PULLDOWN_P_R 1.95695f
C623 PULLUP_P_BLEED_5 PULLDOWN_N_R 0.09196f
C624 FS_P_BLEED_3 PULLUP_P_WELL 0
C625 PULLUP_P_BLEED_4 PULLUP_P_BLEED_2 0.00855f
C626 HS_PBIAS HS_P_4 8.54683f
C627 HS_N FS_P_BLEED_0 0.07763f
C628 HS_N_8 PULLDOWN_P_R 0.02404f
C629 HS_N_4 DIV_ENABLE 0.03089f
C630 FS_N_BLEED_3 FS_LOW_N 0
C631 TERM_P_R FS_N_BLEED_4 0.04588f
C632 HS_N_1 TERM_P_R 0.10227f
C633 FS_N_OUT PULLUP_P_WELL 0.14446f
C634 PULLUP_P_BLEED_6 PULLDOWN_P_R 0.09395f
C635 FS_HIGH_N HS_N 0.05082f
C636 TERM_ENABLE HS_P_9 0.07435f
C637 TERM_GATE_P_BLEED_1 TERM_OR_P_B 0.00371f
C638 HS_N_0 FS_P_BLEED_5 0.06178f
C639 FS_P_GATE FS_HIGH_P 0.48445f
C640 PULLUP_P TERM_OR_N_S 0.14657f
C641 FS_HIGH_N PULLUP_N_BLEED_2 0.00933f
C642 TERM_GATE_P_BLEED_1 TERM_GATE_P 0.37616f
C643 DIV_P HS_N_0 0.03388f
C644 TERM_N_R FS_N_CONTROL_S 0.05859f
C645 HS_N_9 PULLDOWN_P_R 0.02404f
C646 FS_LOW_N HS_N_4 0.04574f
C647 FS_P_OUT HS_P_12 0.10923f
C648 FS_P_BLEED_2 PULLDOWN_N_R 0.05445f
C649 FS_N_BLEED_5 TERM_ENABLE 0.11535f
C650 PULLUP_P PULLUP_N_OUT 29.5964f
C651 FS_P_OUT RX_N 0.00505f
C652 PULLUP_P TERM_GATE_N 0.26296f
C653 TERM_ENABLE TERM_OR_P_B 5.36669f
C654 TERM_GATE_N_BLEED_1 TERM_N_R 0.20108f
C655 HS_P_0 TERM_GATE_P_BLEED_0 0.00591f
C656 VDD HS_N_1 5.26905f
C657 VDD FS_N_BLEED_4 0.0157f
C658 HS_N_6 TERM_GATE_N_BLEED_1 0.03489f
C659 TERM_N_R DIFF_ENABLE 4.32386f
C660 TERM_ENABLE TERM_GATE_P 1.60491f
C661 HS_N_1 HS_N_8 0.04294f
C662 a_41005_203545# a_43813_189064# 2.2693f
C663 a_41005_205505# a_41005_206065# 0.0346f
C664 HS_N HS_P_10 0.34498f
C665 TERM_ENABLE HS_P_5 0.02404f
C666 HS_N_5 TERM_OR_P_B 0.07211f
C667 FS_P_BLEED_3 FS_LOW_P 0.0781f
C668 TERM_N_R TERM_OR_P_S 0.0546f
C669 ESD_RAIL a_53878_205785# 0.53942f
C670 PULLUP_P_BLEED_6 HS_N_1 0.02451f
C671 HS_P_7 HS_P_2 0.06184f
C672 HS_N_5 TERM_GATE_P 0.11502f
C673 HS_P_8 HS_P_3 0.03109f
C674 TERM_P_R HS_N_2 0.0594f
C675 DIV_LOW_N PULLUP_N_OUT 0.04911f
C676 HS_P_9 PULLDOWN_P_R 0.07466f
C677 HS_P_8 VCM_LOW_OK 0.03489f
C678 HS_N HS_P_1 0.75007f
C679 FS_N_OUT FS_LOW_P 0.44039f
C680 PULLUP_N_OUT FS_P_BLEED_1 0.11535f
C681 HS_N_5 HS_P_5 0.10295f
C682 DIV_LOW_N TERM_GATE_N 0.02985f
C683 HS_N_7 VCM_LOW_OK 0.03566f
C684 FS_N_BLEED_3 PULLDOWN_N_R 0.09111f
C685 HS_N_9 HS_N_1 0.04294f
C686 HS_P_11 HS_P_10 48.3384f
C687 DIV_P DIV_LOW_P 0.50398f
C688 TERM_P_R DIV_ENABLE 0
C689 FS_N_OUT HS_PBIAS 0.93594f
C690 PULLDOWN_P PULLUP_N_BLEED_0 0.00106f
C691 HS_P_10 HS_P_4 0
C692 HS_P_7 HS_P 0.53303f
C693 PULLUP_N_GATE FS_HIGH_P 0.00415f
C694 HS_P_11 HS_P_1 0.05935f
C695 TERM_GATE_N_BLEED_2 FS_HIGH_P 0.01347f
C696 PULLDOWN_P_R TERM_OR_P_B 0.17949f
C697 HS_N_4 PULLDOWN_N_R 0.02404f
C698 HS_N_0 HS_N_13 0.07747f
C699 HS_N HS_P_6 0.5265f
C700 HS_P_4 HS_P_1 0.03207f
C701 HS_N_10 FS_P_BLEED_5 0.06178f
C702 FS_LOW_N TERM_P_R 0.10507f
C703 VDD HS_N_2 4.87598f
C704 PULLDOWN_P_R TERM_GATE_P 0.30143f
C705 PULLUP_P PULLUP_N_BLEED_3 0
C706 VDD FS_N_BLEED_0 0
C707 PULLUP_P TERM_ENABLE 0.09052f
C708 HS_N_8 HS_N_2 0
C709 FS_N_BLEED_1 FS_N_BLEED_2 3.07801f
C710 PAD_N HS_P_3 0.257f
C711 HS_P_5 PULLDOWN_P_R 0.02404f
C712 FS_P_BLEED_0 FS_N_OUT 0.28479f
C713 PULLUP_P_OUT HS_N_0 0.02689f
C714 VDD DIV_ENABLE 0.14629f
C715 FS_P_BLEED_2 FS_P_WELL 0.02376f
C716 TERM_VCM FS_P_BLEED_2 0.03472f
C717 HS_P_8 TERM_GATE_P_BLEED_0 0.0271f
C718 PULLUP_N_BLEED_6 TERM_ENABLE 0.08954f
C719 HS_N_8 DIV_ENABLE 0.03089f
C720 PULLUP_P_BLEED_6 HS_N_2 0.02404f
C721 PULLUP_P HS_N_5 0
C722 FS_HIGH_N FS_N_OUT 0.0203f
C723 HS_P_11 HS_P_6 0.06713f
C724 BYPASS_ENABLE PAD_N 11.6896f
C725 DIV_N HS_P_6 0
C726 HS_N_7 TERM_GATE_P_BLEED_0 0
C727 HS_N HS_P_13 0.35374f
C728 HS_N_12 HS_N_0 0.03942f
C729 HS_N_11 TERM_N_R 0.05996f
C730 HS_P_6 HS_P_4 0.06956f
C731 HS_P FS_N_CONTROL_S 0.09193f
C732 HS_N PAD_P 1.23865f
C733 PULLUP_N_BLEED_5 PULLUP_N_BLEED_1 0.00449f
C734 HS_N_9 HS_N_2 0
C735 FS_N_BLEED_5 FS_N_BLEED_4 7.71303f
C736 HS_N_6 HS_N_11 0
C737 TERM_GATE_N_BLEED_1 HS_N_3 0.03489f
C738 PULLUP_N DIFF_ENABLE 0.13679f
C739 VDD FS_LOW_N 1.86145f
C740 DIV_LOW_N TERM_ENABLE 0.04513f
C741 FS_LOW_N HS_N_8 0.04574f
C742 TERM_ENABLE FS_P_BLEED_1 0.11038f
C743 HS_N_1 TERM_OR_P_B 0.07438f
C744 HS_N_9 DIV_ENABLE 0.03089f
C745 HS_N_13 DIV_LOW_P 0.00103f
C746 HS_P_13 HS_P_11 0.08851f
C747 HS_P TERM_GATE_N_BLEED_1 0.03489f
C748 DIV_LOW_N HS_N_5 0.06178f
C749 HS_N_1 TERM_GATE_P 0.10974f
C750 PULLUP_P_BLEED_6 FS_LOW_N 0.08298f
C751 HS_P_11 PAD_P 1.25724f
C752 DIV_N PAD_P 0.45367f
C753 PULLUP_P_BLEED_1 PULLDOWN_N_R 0.00195f
C754 HS_P_13 HS_P_4 0.14463f
C755 HS_N_5 FS_P_BLEED_1 0.06178f
C756 HS_P DIFF_ENABLE 0.1651f
C757 PULLUP_N_OUT FS_P_BLEED_6 0.05922f
C758 PULLUP_P PULLDOWN_P_R 0
C759 HS_N_1 HS_P_5 0.03489f
C760 PULLUP_P_BLEED_4 HS_N_0 0.03489f
C761 PAD_P HS_P_4 1.13663f
C762 HS_P_7 FS_LOW_P 0.04566f
C763 PULLUP_P_BLEED_0 HS_N_6 0
C764 TERM_P_R PULLDOWN_N_R 0.17892f
C765 FS_P_OUT TERM_N_R 0.38548f
C766 PULLDOWN_P TERM_N_R 0.31604f
C767 HS_N_9 FS_LOW_N 0.08747f
C768 HS_P_12 HS_N_6 0.06578f
C769 HS_P_7 HS_PBIAS 0.78499f
C770 HS_N_4 FS_P_WELL 1.93132f
C771 HS_N_6 PULLDOWN_P 0.04428f
C772 FS_P_OUT HS_N_6 0.43331f
C773 HS_N_12 DIV_LOW_P 0.00136f
C774 HS_N_4 TERM_VCM 0.12576f
C775 HS_N_10 HS_N_13 0.03794f
C776 FS_P_BLEED_4 HS_N_11 0.029f
C777 HS_N FS_P_GATE 2.2707f
C778 FS_N_BLEED_3 FS_N_BLEED_6 0.0078f
C779 FS_N_BLEED_3 PULLUP_N_WELL 0
C780 TERM_OR_P_NS PULLDOWN_N_R 0.04591f
C781 a_44789_189064# a_41005_203545# 0.02879f
C782 FS_P_GATE PULLUP_P_GATE 0.05697f
C783 FS_N_BLEED_5 FS_N_BLEED_0 0.10542f
C784 FS_P_BLEED_1 PULLDOWN_P_R 0.10124f
C785 HS_N_5 FS_P_CONTROL_S 0.03226f
C786 PULLUP_P_OUT HS_N_10 0.02545f
C787 HS_N_2 TERM_OR_P_B 0.07258f
C788 HS_N_7 TERM_OR_N_B 0.02846f
C789 VDD PULLDOWN_N_R 3.41738f
C790 PULLUP_P FS_N_BLEED_4 0.10124f
C791 HS_N HS_P_0 0.54906f
C792 HS_N_8 PULLDOWN_N_R 0.06832f
C793 PULLDOWN_P PULLUP_N_CONTROL_S 0.03065f
C794 FS_P_GATE DIV_N 0.09711f
C795 HS_N_2 TERM_GATE_P 0.10747f
C796 PULLUP_P HS_N_1 0.05062f
C797 FS_N_OUT HS_P_6 0.06167f
C798 HS_N_12 HS_N_10 0.011f
C799 ESD_RAIL a_53878_204665# 0.53916f
C800 FS_LOW_P FS_N_CONTROL_S 0.04634f
C801 DIV_ENABLE TERM_OR_P_B 0
C802 HS_P_5 HS_N_2 0.03489f
C803 PULLUP_N_BLEED_0 TERM_N_R 0.11444f
C804 PULLUP_N_OUT PULLUP_P_BLEED_2 0
C805 PULLUP_P_BLEED_6 PULLDOWN_N_R 0.09196f
C806 HS_N_11 HS_N_3 0.06439f
C807 HS_PBIAS FS_N_CONTROL_S 0.09193f
C808 DIV_ENABLE TERM_GATE_P 0.00432f
C809 VCM_LOW_OK TERM_GATE_P_BLEED_2 0.01429f
C810 TERM_GATE_N_BLEED_1 FS_LOW_P 0.06271f
C811 TERM_ENABLE FS_P_BLEED_6 0.00258f
C812 HS_P_5 DIV_ENABLE 0.00252f
C813 DIV_P VCM_LOW_OK 0.00892f
C814 FS_LOW_N FS_N_BLEED_5 0
C815 FS_LOW_P DIFF_ENABLE 0.22091f
C816 HS_P HS_N_11 0.76455f
C817 HS_P_11 HS_P_0 0.06445f
C818 ESD_RAIL a_53878_205225# 0.53916f
C819 TERM_GATE_N_BLEED_1 HS_PBIAS 0.04828f
C820 HS_N_9 PULLDOWN_N_R 0.02404f
C821 DIV_P BYPASS_ENABLE 0.05958f
C822 DIV_LOW_N HS_N_1 0.06926f
C823 FS_N_OUT PAD_P 0.17964f
C824 HS_PBIAS DIFF_ENABLE 0.17138f
C825 HS_P_12 HS_P_2 0.00206f
C826 HS_P_4 HS_P_0 0.00219f
C827 HS_N_1 FS_P_BLEED_1 0.06178f
C828 PULLUP_P_BLEED_4 HS_N_10 0.03489f
C829 FS_LOW_P TERM_OR_P_S 0.36544f
C830 HS_N_5 FS_P_BLEED_6 0.06178f
C831 PULLUP_N_BLEED_4 PULLUP_N_BLEED_3 2.05029f
C832 TERM_N_R TERM_GATE_N_BLEED_0 0.16943f
C833 PULLUP_N_BLEED_0 PULLUP_N_CONTROL_S 0.00553f
C834 HS_N_11 PULLUP_P_WELL 0.2035f
C835 TERM_P_R FS_P_WELL 1.41439f
C836 TERM_P_R TERM_VCM 0.19786p
C837 HS_P_12 HS_N_3 0.03489f
C838 PULLDOWN_P PULLUP_N 5.71742f
C839 HS_N PULLUP_N_GATE 0.17972f
C840 FS_P_OUT HS_N_3 0.48792f
C841 HS_P_7 HS_P_10 0.10683f
C842 FS_HIGH_N FS_N_CONTROL_S 5.89986f
C843 HS_P PULLUP_P_BLEED_0 0.00154f
C844 HS_N TERM_GATE_N_BLEED_2 0.10264f
C845 HS_P_12 HS_P 3.63983f
C846 PULLUP_N_GATE PULLUP_N_BLEED_2 0.06887f
C847 HS_P_7 HS_P_1 0.05962f
C848 FS_P_OUT HS_P 0.68531f
C849 HS_P_9 PULLDOWN_N_R 4.1634f
C850 FS_N_GATE HS_N_13 0.19945f
C851 TERM_P_R FS_N_BLEED_6 0.04766f
C852 PULLUP_P DIV_ENABLE 0.05062f
C853 TERM_GATE_P_BLEED_2 TERM_GATE_P_BLEED_0 0.10759f
C854 FS_P_GATE FS_P_BLEED_3 0.11478f
C855 FS_P_BLEED_6 PULLDOWN_P_R 0.11255f
C856 TERM_VCM TERM_OR_P_NS 0.0013f
C857 PULLUP_P_BLEED_0 PULLUP_P_WELL 2.68055f
C858 HS_N HS_P_8 0.19016f
C859 TERM_P_R PULLUP_N_WELL 0.25282f
C860 a_41005_206065# m2_42279_196800# 0
C861 TERM_GATE_N_BLEED_2 DIV_N 0
C862 FS_HIGH_N DIFF_ENABLE 0.25832f
C863 HS_N_1 FS_P_CONTROL_S 0.0324f
C864 TERM_ENABLE PULLUP_P_BLEED_2 0.08221f
C865 HS_N HS_N_7 0.69419f
C866 VDD FS_P_WELL 99.9304f
C867 VDD TERM_VCM 40.3313f
C868 FS_P_GATE FS_N_OUT 0.35576f
C869 HS_N_8 FS_P_WELL 1.95096f
C870 FS_N_BLEED_5 PULLDOWN_N_R 0.08856f
C871 FS_N_BLEED_1 FS_N_BLEED_4 0.12236f
C872 HS_N_8 TERM_VCM 0.17659f
C873 HS_N_13 HS_P_3 0.02464f
C874 DIV_LOW_N HS_N_2 0.06178f
C875 PULLUP_P FS_LOW_N 0.06426f
C876 HS_N_13 VCM_LOW_OK 0.03489f
C877 PULLUP_N_BLEED_0 PULLUP_N 0.79203f
C878 FS_P_BLEED_1 HS_N_2 0.06178f
C879 HS_P_7 HS_P_6 31.6746f
C880 BYPASS_ENABLE PULLUP_N_BLEED_1 0.00766f
C881 FS_N_WELL HS_N_10 0.01997f
C882 TERM_OR_P_B PULLDOWN_N_R 0.16954f
C883 PULLUP_P_GATE HS_N_7 0.07492f
C884 HS_N_6 TERM_N_R 0.05893f
C885 PULLUP_P_CONTROL_S HS_N_0 0.03489f
C886 DIV_LOW_N DIV_ENABLE 8.13107f
C887 DIFF_ENABLE PULLDOWN_N 0.12241f
C888 TERM_GATE_P PULLDOWN_N_R 0.26213f
C889 HS_P_8 HS_P_11 0.00792f
C890 HS_N_11 FS_LOW_P 0.08505f
C891 HS_N_12 FS_N_GATE 0.02567f
C892 DIV_N HS_N_7 0.03311f
C893 HS_P_5 PULLDOWN_N_R 0.02411f
C894 PULLUP_P_OUT VCM_LOW_OK 0.20679f
C895 VDD FS_N_BLEED_6 0.45117f
C896 PULLUP_P_OUT HS_P_3 0.05276f
C897 HS_P_11 HS_N_7 0
C898 HS_P_8 HS_P_4 0.0312f
C899 HS_N_11 HS_PBIAS 1.09598f
C900 HS_N_9 FS_P_WELL 1.97228f
C901 VDD PULLUP_N_WELL 22.6537f
C902 HS_N_4 PULLUP_P_BLEED_5 0.0525f
C903 HS_N_9 TERM_VCM 0.14875f
C904 HS_N_12 HS_P_3 0.02482f
C905 HS_N PAD_N 35.6371f
C906 HS_N_1 FS_P_BLEED_6 0.06178f
C907 HS_N_12 VCM_LOW_OK 0.03489f
C908 HS_P_13 HS_P_7 0.14204f
C909 DIV_LOW_N FS_LOW_N 0.06178f
C910 FS_HIGH_P PULLUP_N_BLEED_1 0.094f
C911 HS_P_7 PAD_P 1.52213f
C912 FS_P_CONTROL_S HS_N_2 0.03226f
C913 DIV_ENABLE RX_P 0.88297f
C914 HS_P_12 FS_LOW_P 0.17418f
C915 FS_P_OUT FS_LOW_P 0.53116f
C916 DIV_N PAD_N 0.68859f
C917 HS_P_11 PAD_N 1.42473f
C918 PULLUP_P_BLEED_0 HS_PBIAS 0.01397f
C919 HS_P_12 HS_PBIAS 4.10448f
C920 FS_P_BLEED_0 HS_N_11 0.06178f
C921 FS_N_BLEED_1 FS_N_BLEED_0 1.54554f
C922 FS_P_OUT HS_PBIAS 0.96844f
C923 PAD_N HS_P_4 0.27735f
C924 FS_P_BLEED_4 HS_N_6 0.03585f
C925 HS_P_9 TERM_VCM 0.1405f
C926 HS_N_0 TERM_OR_N_S 0.06384f
C927 PULLUP_P_BLEED_4 VCM_LOW_OK 0.0381f
C928 HS_N_4 FS_P_BLEED_2 0.03472f
C929 PULLDOWN_P HS_PBIAS 0.43878f
C930 PULLUP_P PULLDOWN_N_R 0.05768f
C931 PULLUP_P_OUT TERM_GATE_P_BLEED_0 0.1011f
C932 TERM_GATE_N_BLEED_2 FS_N_OUT 0.06408f
C933 PULLUP_N_OUT HS_N_0 0.05062f
C934 HS_N_12 FS_HIGH_P 0
C935 PULLUP_P_BLEED_4 BYPASS_ENABLE 0.00766f
C936 TERM_N_R PULLUP_P_BLEED_3 0.11444f
C937 PULLUP_N_BLEED_6 PULLDOWN_N_R 0.08243f
C938 HS_N_0 TERM_GATE_N 0.05238f
C939 FS_N_BLEED_5 TERM_VCM 0.13759f
C940 TERM_N_R PULLUP_N 0.22413f
C941 FS_P_BLEED_6 HS_N_2 0.06178f
C942 HS_N_6 HS_P_2 0.03089f
C943 TERM_VCM TERM_OR_P_B 0.06303f
C944 FS_LOW_N FS_N_BLEED_1 0.00106f
C945 TERM_N_R HS_N_3 0.05893f
C946 PULLUP_P_CONTROL_S HS_N_10 0.03489f
C947 TERM_VCM TERM_GATE_P 26.4481f
C948 DIV_LOW_N PULLDOWN_N_R 0.08868f
C949 HS_N_6 HS_N_3 0.00106f
C950 FS_P_BLEED_1 PULLDOWN_N_R 0.10124f
C951 FS_N_WELL FS_N_GATE 0.29176p
C952 HS_P_5 TERM_VCM 0.09615f
C953 FS_N_BLEED_5 FS_N_BLEED_6 9.22595f
C954 HS_P TERM_N_R 0.17334f
C955 PULLUP_P_BLEED_4 FS_HIGH_P 0.16441f
C956 HS_N_11 HS_P_10 0.1403f
C957 FS_HIGH_N PULLDOWN_P 0.03743f
C958 FS_N_BLEED_5 PULLUP_N_WELL 0
C959 HS_P HS_N_6 1.04391f
C960 HS_P_7 HS_P_0 0.00469f
C961 TERM_N_R PULLUP_P_WELL 0.33261f
C962 PULLUP_N_CONTROL_S PULLUP_N 1.77933f
C963 HS_N_13 TERM_OR_N_B 0.02922f
C964 PULLDOWN_P PULLDOWN_N 2.82816f
C965 HS_N_6 PULLUP_P_WELL 0.18412f
C966 FS_N_WELL BYPASS_ENABLE 0.05827f
C967 HS_N FS_P_BLEED_5 0.08043f
C968 TERM_P_R FS_P_BLEED_2 0.04766f
C969 FS_N_OUT PAD_N 4.09186f
C970 HS_P_12 HS_P_10 0.07589f
C971 PULLUP_P_BLEED_5 HS_N_8 0.0525f
C972 HS_N DIV_P 0.08005f
C973 FS_P_BLEED_4 HS_N_3 0.03168f
C974 HS_N_0 TERM_ENABLE 0.10336f
C975 HS_P PULLUP_N_CONTROL_S 0.03228f
C976 HS_N_10 TERM_OR_N_S 0.06335f
C977 PULLUP_P_GATE FS_P_BLEED_5 0
C978 PULLUP_P TERM_VCM 0.24287f
C979 HS_N_11 HS_P_6 0.05932f
C980 PULLUP_P_BLEED_6 PULLUP_P_BLEED_5 4.72363f
C981 HS_P_12 HS_P_1 0.05935f
C982 HS_N_12 TERM_OR_N_B 0.02944f
C983 HS_P FS_P_BLEED_4 0.08804f
C984 HS_N_0 HS_N_5 0.03911f
C985 HS_N_10 TERM_GATE_N 0.04869f
C986 PULLUP_N_BLEED_6 TERM_VCM 0.02041f
C987 FS_N_WELL FS_HIGH_P 1.63108f
C988 HS_N_9 PULLUP_P_BLEED_5 0.0525f
C989 DIV_P DIV_N 48.6079f
C990 VDD FS_P_BLEED_2 0.44675f
C991 PULLUP_P FS_N_BLEED_6 0.05445f
C992 HS_N_8 FS_P_BLEED_2 0.03472f
C993 HS_P_13 HS_N_11 0.02487f
C994 FS_P_BLEED_4 PULLUP_P_WELL 0
C995 HS_N_11 PAD_P 0.38848f
C996 TERM_N_R FS_LOW_P 0.22736f
C997 DIV_LOW_N TERM_VCM 0.32996f
C998 PULLUP_P PULLUP_N_WELL 8.30565f
C999 FS_P_BLEED_6 PULLDOWN_N_R 0.10378f
C1000 HS_P HS_P_2 7.07711f
C1001 HS_P_12 HS_P_6 0.07018f
C1002 FS_P_BLEED_1 FS_P_WELL 0.11893f
C1003 FS_P_OUT HS_P_6 0.15673f
C1004 FS_P_BLEED_1 TERM_VCM 0.08802f
C1005 HS_P_8 HS_P_7 30.9838f
C1006 HS_N_6 FS_LOW_P 0.08542f
C1007 TERM_ENABLE PULLUP_N_BLEED_5 0.01168f
C1008 HS_P PULLUP_N 0.0019f
C1009 TERM_N_R HS_PBIAS 0.82298f
C1010 HS_P_7 HS_N_7 0
C1011 PULLUP_N_BLEED_5 PULLUP_N_BLEED_3 0.06568f
C1012 HS_N_4 TERM_P_R 0.05893f
C1013 PULLUP_P_WELL PULLUP_P_BLEED_3 0
C1014 HS_N_6 HS_PBIAS 4.87661f
C1015 HS_P HS_N_3 0.17867f
C1016 HS_N_0 PULLDOWN_P_R 0.02508f
C1017 PULLUP_N_BLEED_4 PULLDOWN_N_R 0.08997f
C1018 HS_N PULLUP_N_BLEED_1 0.06167f
C1019 HS_N_9 FS_P_BLEED_2 0.03472f
C1020 HS_P_13 HS_P_12 47.0352f
C1021 PULLUP_P_CONTROL_S VCM_LOW_OK 0.03762f
C1022 PULLUP_N_BLEED_2 PULLUP_N_BLEED_1 5.20556f
C1023 PULLUP_P_WELL HS_N_3 0.18066f
C1024 HS_N HS_N_13 0.98202f
C1025 HS_P_13 FS_P_OUT 0.1275f
C1026 HS_P_12 PAD_P 1.66835f
C1027 HS_N_4 TERM_OR_P_NS 0.00196f
C1028 FS_P_OUT PAD_P 5.92309f
C1029 FS_P_BLEED_0 TERM_N_R 0.05729f
C1030 PAD_P RX_N 0.37917f
C1031 FS_P_CONTROL_S FS_P_WELL 0.19365f
C1032 PULLUP_P_GATE HS_N_13 0.07271f
C1033 HS_P PULLUP_P_WELL 0.29185f
C1034 PULLUP_N_CONTROL_S HS_PBIAS 0.09332f
C1035 HS_N_10 TERM_ENABLE 0.04835f
C1036 TERM_GATE_N_BLEED_2 TERM_GATE_N_BLEED_1 7.29504f
C1037 HS_P_7 PAD_N 0.3613f
C1038 VDD HS_N_4 5.65472f
C1039 FS_P_BLEED_3 FS_P_BLEED_5 0.12831f
C1040 HS_N PULLUP_P_OUT 0.09516f
C1041 a_44789_189064# a_43813_189064# 2.94235f
C1042 FS_P_BLEED_0 HS_N_6 0.06178f
C1043 FS_HIGH_N TERM_N_R 0.09517f
C1044 HS_N_4 HS_N_8 0.04062f
C1045 FS_P_GATE HS_N_11 1.01556f
C1046 DIV_N HS_N_13 0.03311f
C1047 PULLUP_P_OUT PULLUP_P_GATE 18.3667f
C1048 FS_P_BLEED_4 HS_PBIAS 0.08384f
C1049 HS_N_5 HS_N_10 0
C1050 HS_N HS_N_12 8.83112f
C1051 FS_N_GATE FS_N_BLEED_2 0.17946f
C1052 FS_N_OUT FS_P_BLEED_5 0.05624f
C1053 HS_N_1 HS_N_0 0.12463p
C1054 PULLUP_P_BLEED_6 HS_N_4 0.02906f
C1055 DIV_P FS_N_OUT 2.20134f
C1056 HS_P_11 PULLUP_P_OUT 0.05519f
C1057 PULLUP_P_CONTROL_S FS_HIGH_P 0.00941f
C1058 HS_N_12 PULLUP_P_GATE 0.07326f
C1059 TERM_GATE_N_BLEED_1 HS_N_7 0.03489f
C1060 TERM_N_R PULLDOWN_N 0.20696f
C1061 HS_N_11 HS_P_0 0.04389f
C1062 TERM_OR_N_S VCM_LOW_OK 4.63203f
C1063 PULLUP_N_OUT FS_N_GATE 1.09602f
C1064 HS_N_9 HS_N_4 0.03262f
C1065 PULLUP_P_OUT HS_P_4 0.05519f
C1066 FS_N_BLEED_1 FS_N_BLEED_6 0.00763f
C1067 FS_LOW_P HS_P_2 0.04618f
C1068 TERM_OR_N_NS TERM_OR_N_S 0.01635f
C1069 HS_P_11 HS_N_12 0.11035f
C1070 HS_P_12 FS_P_GATE 0.00294f
C1071 HS_PBIAS HS_P_2 3.95109f
C1072 DIV_N HS_N_12 0.03311f
C1073 FS_N_BLEED_1 PULLUP_N_WELL 0
C1074 FS_LOW_P HS_N_3 0.08505f
C1075 FS_P_OUT FS_P_GATE 0.13406p
C1076 TERM_N_R HS_P_10 0.05037f
C1077 PULLUP_N_OUT HS_P_3 0.08633f
C1078 PULLUP_P_BLEED_4 HS_N 0.04828f
C1079 PULLUP_N HS_PBIAS 0.02682f
C1080 PULLUP_N_OUT VCM_LOW_OK 0.15823f
C1081 TERM_GATE_N VCM_LOW_OK 0.0053f
C1082 HS_PBIAS HS_N_3 1.39899f
C1083 HS_N_10 PULLDOWN_P_R 0.02436f
C1084 HS_N_6 HS_P_10 0.03097f
C1085 PULLUP_P_BLEED_4 PULLUP_P_GATE 0.27788f
C1086 HS_P FS_LOW_P 0.09863f
C1087 PULLUP_P_BLEED_1 VDD 0.00371f
C1088 TERM_P_R TERM_OR_P_NS 0.22589f
C1089 HS_P_12 HS_P_0 0.08899f
C1090 HS_P HS_PBIAS 0.16547p
C1091 PULLUP_P PULLUP_P_BLEED_5 0.15607f
C1092 FS_P_OUT HS_P_0 0.09146f
C1093 HS_N_6 HS_P_1 0.03099f
C1094 HS_N_1 DIV_LOW_P 0.00376f
C1095 PULLUP_P_BLEED_4 DIV_N 0.10151f
C1096 HS_N_0 HS_N_2 0.03925f
C1097 PULLUP_P_WELL FS_LOW_P 0.27223f
C1098 VDD TERM_P_R 6.10049f
C1099 FS_N_BLEED_3 FS_N_BLEED_5 0.10633f
C1100 TERM_OR_N_S FS_HIGH_P 0.00369f
C1101 TERM_P_R HS_N_8 0.10054f
C1102 FS_HIGH_P FS_N_BLEED_2 0
C1103 PULLUP_P_WELL HS_PBIAS 0.58979f
C1104 TERM_GATE_N_BLEED_2 HS_N_11 0.05266f
C1105 FS_P_BLEED_0 HS_N_3 0.06178f
C1106 HS_N_0 DIV_ENABLE 1.72358f
C1107 FS_N_OUT HS_N_13 0.00552f
C1108 HS_N_6 HS_P_6 0.06938f
C1109 TERM_GATE_N FS_HIGH_P 0.00415f
C1110 HS_N_4 TERM_OR_P_B 0.07211f
C1111 FS_P_BLEED_0 HS_P 0.06178f
C1112 PULLUP_N_OUT TERM_GATE_P_BLEED_0 0.10679f
C1113 TERM_ENABLE FS_N_GATE 1.03838f
C1114 HS_N_1 HS_N_10 0.12499p
C1115 PULLUP_P_BLEED_2 TERM_VCM 0.01882f
C1116 VDD TERM_OR_P_NS 0.04366f
C1117 HS_N_9 TERM_P_R 0.0592f
C1118 HS_N FS_N_WELL 4.90842f
C1119 HS_N_8 TERM_OR_P_NS 0.00704f
C1120 HS_N_4 TERM_GATE_P 0.11218f
C1121 FS_LOW_N HS_N_0 0.04608f
C1122 PULLUP_N PULLDOWN_N 0.05397f
C1123 HS_N_11 HS_N_7 0.02985f
C1124 FS_HIGH_N HS_P 0.03743f
C1125 HS_N_4 HS_P_5 0.03511f
C1126 HS_N_12 FS_P_BLEED_3 0
C1127 VDD HS_N_8 5.59181f
C1128 TERM_ENABLE HS_P_3 0.0768f
C1129 FS_P_BLEED_0 PULLUP_P_WELL 0
C1130 TERM_ENABLE VCM_LOW_OK 0.15048f
C1131 PULLDOWN_P PULLUP_N_GATE 0.20689f
C1132 TERM_N_R PAD_P 0.18868f
C1133 TERM_GATE_N_BLEED_2 PULLDOWN_P 0.07928f
C1134 HS_N_2 DIV_LOW_P 0
C1135 HS_P_13 HS_N_6 0.05493f
C1136 HS_N_12 FS_N_OUT 0.00528f
C1137 HS_P_10 HS_P_2 0
C1138 HS_N_5 HS_P_3 0.03089f
C1139 PULLUP_P_BLEED_6 HS_N_8 0.04188f
C1140 HS_N_6 PAD_P 2.14046f
C1141 HS_N_9 TERM_OR_P_NS 0.01002f
C1142 HS_N_5 VCM_LOW_OK 0.03535f
C1143 FS_P_BLEED_1 FS_P_BLEED_2 8.68609f
C1144 HS_P_1 HS_P_2 0.0568f
C1145 HS_P_8 HS_P_12 0
C1146 TERM_GATE_P_BLEED_1 TERM_GATE_P_BLEED_0 2.63577f
C1147 DIV_ENABLE DIV_LOW_P 2.67093f
C1148 PULLUP_P_BLEED_0 HS_N_7 0
C1149 TERM_P_R HS_P_9 0.11568f
C1150 VDD HS_N_9 5.06755f
C1151 PULLUP_P FS_N_BLEED_3 0.04819f
C1152 FS_LOW_P HS_PBIAS 0.34356f
C1153 HS_P_12 HS_N_7 0.03489f
C1154 HS_N_11 PAD_N 1.22201f
C1155 HS_N_9 HS_N_8 0.11834p
C1156 FS_P_OUT HS_N_7 0.52477f
C1157 PULLDOWN_P HS_N_7 0.04428f
C1158 HS_P HS_P_10 2.44809f
C1159 PULLUP_P_BLEED_4 FS_N_OUT 0.06167f
C1160 HS_N_10 HS_N_2 0.04415f
C1161 TERM_OR_N_S TERM_OR_N_B 5.00768f
C1162 PULLUP_P_BLEED_6 HS_N_9 0.04869f
C1163 TERM_P_R FS_N_BLEED_5 0.11141f
C1164 PULLUP_N_GATE PULLUP_N_BLEED_0 0.20139f
C1165 TERM_ENABLE FS_HIGH_P 0.02051f
C1166 HS_P HS_P_1 4.17389f
C1167 HS_P_9 TERM_OR_P_NS 0.03937f
C1168 PULLDOWN_P_R HS_P_3 0.07466f
C1169 HS_P_6 HS_P_2 0.06956f
C1170 PULLDOWN_P_R VCM_LOW_OK 0.06553f
C1171 TERM_ENABLE TERM_GATE_P_BLEED_0 0.09803f
C1172 TERM_P_R TERM_OR_P_B 0.76857f
C1173 HS_N_10 DIV_ENABLE 0.03182f
C1174 FS_P_GATE TERM_N_R 0.75462f
C1175 HS_N_0 PULLDOWN_N_R 0.06832f
C1176 PULLUP_N_OUT TERM_OR_N_B 0.13769f
C1177 FS_P_CONTROL_S FS_P_BLEED_2 0
C1178 TERM_GATE_N TERM_OR_N_B 2.35341f
C1179 HS_P_6 HS_N_3 0.05828f
C1180 VDD HS_P_9 6.02581f
C1181 TERM_P_R TERM_GATE_P 26.175f
C1182 HS_P_12 PAD_N 0.22324f
C1183 TERM_P_R HS_P_5 0.08374f
C1184 FS_P_GATE HS_N_6 1.0185f
C1185 HS_N_8 HS_P_9 0.00649f
C1186 HS_N_5 TERM_GATE_P_BLEED_0 0
C1187 FS_P_BLEED_0 HS_PBIAS 0.08856f
C1188 FS_HIGH_N FS_LOW_P 0.0591f
C1189 FS_P_OUT PAD_N 1.89403f
C1190 PAD_N RX_N 9.8031f
C1191 DIV_LOW_N HS_N_4 0.06178f
C1192 HS_P HS_P_6 3.46603f
C1193 FS_LOW_N HS_N_10 0.04615f
C1194 HS_P_13 HS_P_2 36.317f
C1195 FS_HIGH_N HS_PBIAS 0.03743f
C1196 TERM_OR_P_B TERM_OR_P_NS 3.40561f
C1197 HS_N_4 FS_P_BLEED_1 0.06178f
C1198 HS_N PULLUP_P_CONTROL_S 0.04828f
C1199 FS_N_BLEED_4 FS_N_GATE 0.21315f
C1200 VDD FS_N_BLEED_5 0.55431f
C1201 PAD_P HS_P_2 1.20139f
C1202 PULLUP_P_CONTROL_S PULLUP_P_GATE 1.59532f
C1203 TERM_GATE_N_BLEED_2 TERM_GATE_N_BLEED_0 0
C1204 HS_N_6 HS_P_0 0.03737f
C1205 HS_P_13 HS_N_3 0.02404f
C1206 VDD TERM_OR_P_B 16.0128f
C1207 HS_N_9 HS_P_9 0.06704f
C1208 HS_N_8 TERM_OR_P_B 0.07245f
C1209 HS_P_5 TERM_OR_P_NS 0.02846f
C1210 FS_N_WELL FS_N_OUT 0.19821p
C1211 a_42245_162628# ESD_RAIL 0.24219p
C1212 PAD_P HS_N_3 0.09104f
C1213 VDD TERM_GATE_P 7.09843f
C1214 PULLUP_P_CONTROL_S DIV_N 0
C1215 HS_N_1 VCM_LOW_OK 0.03489f
C1216 PULLUP_N_BLEED_5 PULLDOWN_N_R 0.04934f
C1217 HS_N_1 HS_P_3 0.02599f
C1218 VDD HS_P_5 4.75167f
C1219 HS_P_13 HS_P 0.71007f
C1220 HS_N_8 TERM_GATE_P 0.12805f
C1221 PULLDOWN_P_R TERM_GATE_P_BLEED_0 0.12409f
C1222 PULLUP_P_BLEED_1 PULLUP_P 0.27145f
C1223 HS_N_8 HS_P_5 0.05893f
C1224 FS_LOW_P HS_P_10 0.05509f
C1225 HS_P PAD_P 39.8004f
C1226 FS_P_GATE FS_P_BLEED_4 0.29324f
C1227 FS_N_BLEED_3 FS_N_BLEED_1 0.12036f
C1228 PULLUP_P TERM_P_R 0.26978f
C1229 HS_PBIAS HS_P_10 8.55407f
C1230 HS_N_4 FS_P_CONTROL_S 0.03226f
C1231 FS_LOW_P HS_P_1 0.11262f
C1232 HS_N_9 TERM_OR_P_B 0.07254f
C1233 TERM_ENABLE TERM_OR_N_B 0.3874f
C1234 DIFF_ENABLE PULLUP_N_BLEED_1 0.00113f
C1235 TERM_P_R PULLUP_N_BLEED_6 0.04606f
C1236 PULLUP_N_GATE TERM_N_R 0.16855f
C1237 HS_N TERM_OR_N_S 0.11245f
C1238 HS_PBIAS HS_P_1 2.59892f
C1239 HS_N_9 TERM_GATE_P 0.13605f
C1240 HS_N FS_N_BLEED_2 0.11535f
C1241 TERM_GATE_N_BLEED_1 HS_N_13 0.03489f
C1242 TERM_GATE_N_BLEED_2 TERM_N_R 0.11565f
C1243 HS_N_9 HS_P_5 0.06578f
C1244 HS_N_0 FS_P_WELL 2.56674f
C1245 HS_N_11 FS_P_BLEED_5 0.06178f
C1246 HS_N_10 PULLDOWN_N_R 0.02404f
C1247 HS_N_5 TERM_OR_N_B 0.02846f
C1248 HS_N_0 TERM_VCM 0.18419f
C1249 FS_N_GATE FS_N_BLEED_0 0.10419f
C1250 TERM_GATE_N_BLEED_2 HS_N_6 0.0525f
C1251 FS_N_BLEED_4 FS_HIGH_P 0
C1252 HS_N PULLUP_N_OUT 0.10855f
C1253 FS_P_GATE HS_N_3 1.011f
C1254 HS_N_1 FS_HIGH_P 0
C1255 FS_N_GATE DIV_ENABLE 0.00451f
C1256 TERM_P_R FS_P_BLEED_1 0.10934f
C1257 DIV_N TERM_OR_N_S 0
C1258 HS_N TERM_GATE_N 0.08686f
C1259 FS_LOW_P HS_P_6 0.04566f
C1260 PULLUP_P VDD 2.44148f
C1261 HS_N_2 HS_P_3 0.02451f
C1262 PULLUP_P HS_N_8 0.05062f
C1263 HS_N_2 VCM_LOW_OK 0.03489f
C1264 PULLUP_N_OUT PULLUP_P_GATE 0.29848f
C1265 HS_P_9 TERM_OR_P_B 0.1442f
C1266 HS_PBIAS HS_P_6 2.09103f
C1267 HS_N_12 TERM_GATE_N_BLEED_1 0.03489f
C1268 TERM_N_R HS_N_7 0.1093f
C1269 HS_N_4 FS_P_BLEED_6 0.06178f
C1270 HS_P_0 HS_P_2 0.00431f
C1271 FS_P_GATE HS_P 1.03424f
C1272 VDD PULLUP_N_BLEED_6 0.0157f
C1273 PULLUP_P_OUT TERM_OR_P_S 0.00441f
C1274 HS_P_9 TERM_GATE_P 0.22051f
C1275 PULLUP_N_OUT DIV_N 0
C1276 PULLUP_P_BLEED_6 PULLUP_P 0.14694f
C1277 PULLUP_N_GATE PULLUP_N_CONTROL_S 1.19294f
C1278 HS_N_6 HS_N_7 0.11975p
C1279 PULLUP_N_OUT HS_P_11 0.08824f
C1280 DIV_N TERM_GATE_N 0.01703f
C1281 HS_P_9 HS_P_5 0
C1282 FS_LOW_N FS_N_GATE 0.79269f
C1283 HS_P_13 FS_LOW_P 0.04601f
C1284 PULLUP_N_OUT HS_P_4 0.0863f
C1285 FS_P_GATE PULLUP_P_WELL 0.00565f
C1286 DIV_P HS_P_12 0.03388f
C1287 BYPASS_ENABLE DIV_ENABLE 74.5289f
C1288 DIV_P RX_N 0.37599f
C1289 VDD DIV_LOW_N 0.00118f
C1290 PULLUP_P_CONTROL_S FS_N_OUT 0.06167f
C1291 DIV_P FS_P_OUT 0.01279f
C1292 HS_P_13 HS_PBIAS 2.35188f
C1293 HS_P HS_P_0 17.7665f
C1294 VDD FS_P_BLEED_1 0.62129f
C1295 DIV_LOW_N HS_N_8 0.06178f
C1296 FS_LOW_N VCM_LOW_OK 0.0742f
C1297 HS_N_8 FS_P_BLEED_1 0.06178f
C1298 TERM_GATE_P TERM_OR_P_B 12.9405f
C1299 TERM_VCM DIV_LOW_P 0.00257f
C1300 TERM_OR_N_NS FS_LOW_N 0.70648f
C1301 TERM_N_R PAD_N 0.08909f
C1302 HS_P_5 TERM_OR_P_B 0.10156f
C1303 HS_N_2 FS_HIGH_P 0.01124f
C1304 FS_HIGH_P FS_N_BLEED_0 0.014f
C1305 HS_N_6 PAD_N 1.1595f
C1306 HS_P_5 TERM_GATE_P 0.15599f
C1307 HS_N TERM_ENABLE 0.06822f
C1308 HS_N PULLUP_N_BLEED_3 0.06387f
C1309 DIV_LOW_N HS_N_9 0.06178f
C1310 FS_HIGH_P DIV_ENABLE 4.86815f
C1311 HS_N_11 HS_N_13 0.10514f
C1312 PULLUP_N_GATE PULLUP_N 1.51486f
C1313 FS_P_BLEED_4 HS_N_7 0.03872f
C1314 HS_P_10 HS_P_1 37.0279f
C1315 HS_N_9 FS_P_BLEED_1 0.06178f
C1316 HS_N_10 FS_P_WELL 2.01635f
C1317 PULLUP_N_BLEED_2 PULLUP_N_BLEED_3 3.56186f
C1318 HS_N_10 TERM_VCM 0.12019f
C1319 TERM_ENABLE PULLUP_P_GATE 0.88804f
C1320 HS_N HS_N_5 4.65354f
C1321 HS_N_1 TERM_OR_N_B 0.03096f
C1322 TERM_GATE_N_BLEED_2 HS_N_3 0.0525f
C1323 VDD FS_P_CONTROL_S 0.38621f
C1324 PULLUP_P_OUT HS_N_11 0.02508f
C1325 HS_P PULLUP_N_GATE 0.1185f
C1326 HS_N_8 FS_P_CONTROL_S 0.03238f
C1327 FS_N_OUT TERM_OR_N_S 0.0683f
C1328 FS_N_WELL FS_N_CONTROL_S 0.72893f
C1329 HS_P_8 HS_P_2 0.03103f
C1330 DIV_N TERM_ENABLE 0.00135f
C1331 FS_N_GATE PULLDOWN_N_R 1.20308f
C1332 FS_P_GATE FS_LOW_P 0.55947f
C1333 FS_LOW_N FS_HIGH_P 93.86971f
C1334 HS_P_11 TERM_ENABLE 0.07923f
C1335 HS_N_5 PULLUP_P_GATE 0.07376f
C1336 HS_P TERM_GATE_N_BLEED_2 0.0525f
C1337 PULLUP_P FS_N_BLEED_5 0.10124f
C1338 HS_P_10 HS_P_6 0.07646f
C1339 HS_N_12 HS_N_11 0.13666p
C1340 TERM_ENABLE HS_P_4 0.07923f
C1341 FS_P_GATE HS_PBIAS 1.76849f
C1342 PULLDOWN_P PULLUP_N_BLEED_1 0.04153f
C1343 HS_P_12 HS_N_13 0.03621f
C1344 PULLDOWN_N_R HS_P_3 0.07217f
C1345 TERM_P_R PULLUP_N_BLEED_4 0
C1346 PULLUP_N_OUT FS_N_OUT 0.50336f
C1347 HS_P_11 HS_N_5 0.03089f
C1348 FS_P_OUT HS_N_13 0.52823f
C1349 HS_N_7 HS_N_3 0.02877f
C1350 DIV_N HS_N_5 0.03311f
C1351 FS_N_OUT TERM_GATE_N 0.05082f
C1352 PULLDOWN_P HS_N_13 0.04428f
C1353 VCM_LOW_OK PULLDOWN_N_R 0.09092f
C1354 HS_P_6 HS_P_1 0.06271f
C1355 HS_P_8 HS_P 3.0077f
C1356 HS_N_5 HS_P_4 0.13307f
C1357 FS_LOW_P HS_P_0 0.0932f
C1358 HS_N_9 FS_P_CONTROL_S 0.03242f
C1359 HS_N PULLDOWN_P_R 0.04388f
C1360 HS_P HS_N_7 0.33458f
C1361 VDD FS_P_BLEED_6 0.00118f
C1362 FS_P_OUT PULLUP_P_OUT 0.56159f
C1363 HS_PBIAS HS_P_0 0.94883f
C1364 HS_P_13 HS_P_10 0.09466f
C1365 HS_N_8 FS_P_BLEED_6 0.06178f
C1366 PAD_N HS_P_2 2.43754f
C1367 PULLUP_P_BLEED_4 HS_N_11 0.03489f
C1368 PULLUP_P_GATE PULLDOWN_P_R 0.24897f
C1369 HS_P_10 PAD_P 1.26307f
C1370 HS_P_12 HS_N_12 0.08272f
C1371 HS_N_2 TERM_OR_N_B 0.02905f
C1372 FS_P_BLEED_0 FS_P_GATE 0.22183f
C1373 PULLUP_P_WELL HS_N_7 0.19018f
C1374 FS_P_OUT HS_N_12 0.43801f
C1375 PULLUP_P_BLEED_1 PULLUP_P_BLEED_2 0.76129f
C1376 PULLUP_P_BLEED_5 HS_N_0 0.05292f
C1377 HS_P_13 HS_P_1 0.11352f
C1378 PULLDOWN_P HS_N_12 0.05194f
C1379 HS_P_11 PULLDOWN_P_R 0.07466f
C1380 PULLUP_N_BLEED_0 PULLUP_N_BLEED_1 4.9716f
C1381 PAD_N HS_N_3 1.66755f
C1382 PAD_P HS_P_1 1.23389f
C1383 PULLDOWN_P_R HS_P_4 0.07466f
C1384 TERM_P_R PULLUP_P_BLEED_2 0.04588f
C1385 HS_P PAD_N 1.82419f
C1386 HS_N_9 FS_P_BLEED_6 0.06178f
C1387 TERM_GATE_P_BLEED_0 PULLDOWN_N_R 0.0553f
C1388 PULLUP_P_BLEED_4 PULLUP_P_BLEED_0 0.00257f
C1389 HS_N FS_N_BLEED_4 0.11535f
C1390 TERM_N_R TERM_GATE_P_BLEED_2 0.8432f
C1391 HS_N_6 FS_P_BLEED_5 0.06231f
C1392 PULLUP_N_GATE FS_LOW_P 0.04939f
C1393 HS_P_13 HS_P_6 0.15959f
C1394 HS_N HS_N_1 3.90933f
C1395 HS_N_0 FS_P_BLEED_2 0.03472f
C1396 TERM_GATE_N_BLEED_2 FS_LOW_P 0.05872f
C1397 PULLUP_P_BLEED_4 PULLDOWN_P 0
C1398 FS_LOW_N TERM_OR_N_B 1.10292f
C1399 PULLUP_N_GATE HS_PBIAS 0.16144f
C1400 HS_P_6 PAD_P 1.8306f
C1401 FS_N_OUT TERM_ENABLE 0.53478f
C1402 PULLUP_P PULLUP_N_BLEED_6 0.10721f
C1403 HS_N_1 PULLUP_P_GATE 0.07485f
C1404 TERM_GATE_N_BLEED_2 HS_PBIAS 0.07928f
C1405 FS_N_GATE TERM_VCM 0.98062f
C1406 FS_N_BLEED_1 FS_N_BLEED_5 0.10542f
C1407 FS_N_WELL HS_N_11 0.01997f
C1408 VDD PULLUP_P_BLEED_2 0.0176f
C1409 HS_P_8 FS_LOW_P 0.04566f
C1410 HS_N_1 DIV_N 0.03451f
C1411 TERM_VCM HS_P_3 0.12019f
C1412 HS_P_11 HS_N_1 0.02846f
C1413 VCM_LOW_OK FS_P_WELL 1.21662f
C1414 TERM_VCM VCM_LOW_OK 0.10422p
C1415 FS_LOW_P HS_N_7 0.0855f
C1416 PULLUP_P DIV_LOW_N 0.04819f
C1417 HS_P_8 HS_PBIAS 1.54227f
C1418 TERM_OR_N_NS TERM_VCM 0.05974f
C1419 FS_N_GATE FS_N_BLEED_6 1.43361f
C1420 HS_P_13 PAD_P 1.35247f
C1421 PULLUP_N_OUT HS_P_7 0.02846f
C1422 HS_PBIAS HS_N_7 7.23833f
C1423 BYPASS_ENABLE FS_P_WELL 0.05062f
C1424 BYPASS_ENABLE TERM_VCM 0.00889f
C1425 HS_P_10 HS_P_0 2.2381f
C1426 FS_P_BLEED_4 FS_P_BLEED_5 1.99363f
C1427 FS_HIGH_N PULLUP_N_GATE 0.00262f
C1428 HS_N HS_N_2 6.79185f
C1429 PULLUP_P_BLEED_5 HS_N_10 0.0527f
C1430 HS_P_1 HS_P_0 36.4065f
C1431 HS_N FS_N_BLEED_0 0.02118f
C1432 TERM_N_R PULLUP_N_BLEED_1 0.06105f
C1433 FS_N_WELL PULLDOWN_P 2.66844f
C1434 BYPASS_ENABLE FS_N_BLEED_6 0.00766f
C1435 TERM_OR_N_B PULLDOWN_N_R 0.08064f
C1436 PULLUP_P_GATE HS_N_2 0.07258f
C1437 HS_N_4 HS_N_0 0.03919f
C1438 FS_HIGH_P FS_P_WELL 1.18988f
C1439 HS_N DIV_ENABLE 0.05802f
C1440 TERM_N_R HS_N_13 0.05952f
C1441 BYPASS_ENABLE PULLUP_N_WELL 0.00823f
C1442 PULLUP_N_GATE PULLDOWN_N 0.00133f
C1443 FS_P_BLEED_0 HS_N_7 0.06178f
C1444 FS_HIGH_P TERM_VCM 0.13567f
C1445 HS_N_6 HS_N_13 0.08101f
C1446 PULLUP_P_GATE DIV_ENABLE 0
C1447 DIV_N HS_N_2 0.03311f
C1448 PULLUP_N_OUT FS_N_CONTROL_S 0.1046f
C1449 PULLUP_N_BLEED_2 DIV_ENABLE 0
C1450 HS_P_11 HS_N_2 0.03089f
C1451 FS_P_BLEED_5 HS_N_3 0.06178f
C1452 HS_P_13 FS_P_GATE 0.19446f
C1453 PULLUP_P_OUT TERM_N_R 0.14287f
C1454 HS_P_6 HS_P_0 0.04603f
C1455 HS_N_10 FS_P_BLEED_2 0.03472f
C1456 DIV_P HS_N_3 0.03388f
C1457 HS_N FS_LOW_N 0.07689f
C1458 PULLUP_P_OUT HS_N_6 0.02404f
C1459 HS_N_1 FS_P_BLEED_3 0
C1460 DIV_N DIV_ENABLE 33.0014f
C1461 PULLUP_N_OUT TERM_GATE_N_BLEED_1 0.05462f
C1462 FS_HIGH_P FS_N_BLEED_6 0.09407f
C1463 HS_P FS_P_BLEED_5 0.06337f
C1464 PULLUP_N_CONTROL_S PULLUP_N_BLEED_1 0
C1465 TERM_GATE_N_BLEED_1 TERM_GATE_N 0.56312f
C1466 FS_LOW_N PULLUP_N_BLEED_2 0.08389f
C1467 HS_N_12 TERM_N_R 0.0597f
C1468 DIV_P HS_P 0.08005f
C1469 FS_HIGH_P PULLUP_N_WELL 0.21354f
C1470 HS_P_7 TERM_ENABLE 0.02404f
C1471 HS_N_6 HS_N_12 0
C1472 FS_P_BLEED_1 FS_P_CONTROL_S 0.00276f
C1473 PULLUP_P_CONTROL_S HS_N_11 0.03489f
C1474 HS_P_13 HS_P_0 0.01899f
C1475 PULLUP_P_WELL FS_P_BLEED_5 0
C1476 FS_LOW_N DIV_N 0.03543f
C1477 HS_P_8 HS_P_10 0.00926f
C1478 FS_P_BLEED_4 HS_N_13 0.02846f
C1479 PAD_P HS_P_0 1.64024f
C1480 HS_P_10 HS_N_7 0
C1481 HS_P_8 HS_P_1 0.02404f
C1482 PULLUP_P PULLUP_N_BLEED_4 0
C1483 PULLUP_P_BLEED_4 TERM_N_R 0.06105f
C1484 HS_N_7 HS_P_1 0
C1485 PULLUP_P_BLEED_4 HS_N_6 0.03489f
C1486 TERM_P_R HS_N_0 0.09876f
C1487 PULLUP_P_CONTROL_S PULLUP_P_BLEED_0 0
C1488 PULLUP_N_BLEED_6 PULLUP_N_BLEED_4 0
C1489 PULLUP_N PULLUP_N_BLEED_1 0.54926f
C1490 TERM_ENABLE FS_N_CONTROL_S 0.07644f
C1491 HS_N_4 HS_N_10 0
C1492 TERM_VCM TERM_OR_N_B 0.02456f
C1493 HS_P_7 PULLDOWN_P_R 0.02411f
C1494 FS_P_BLEED_4 HS_N_12 0.02888f
C1495 HS_N PULLDOWN_N_R 0.03055f
C1496 HS_P_8 HS_P_6 0.00206f
C1497 HS_P_10 PAD_N 0.42477f
C1498 HS_N_11 TERM_OR_N_S 0.06335f
C1499 HS_N_13 HS_N_3 0.30894f
C1500 FS_N_OUT HS_N_2 0.06167f
C1501 TERM_GATE_N_BLEED_1 TERM_ENABLE 0.04881f
C1502 PULLUP_N_BLEED_2 PULLDOWN_N_R 0.07928f
C1503 HS_P_6 HS_N_7 0.02536f
C1504 HS_P PULLUP_N_BLEED_1 0.04828f
C1505 FS_P_BLEED_3 DIV_ENABLE 0
C1506 PULLUP_P_OUT HS_P_2 0.06773f
C1507 PULLUP_P_GATE PULLDOWN_N_R 0.22243f
C1508 TERM_ENABLE DIFF_ENABLE 0.03355f
C1509 ESD_RAIL a_41005_204385# 0.53823f
C1510 PAD_N HS_P_1 0.56708f
C1511 HS_P HS_N_13 0.10519f
C1512 VDD HS_N_0 4.92227f
C1513 TERM_GATE_N_BLEED_1 HS_N_5 0.03489f
C1514 TERM_ENABLE TERM_OR_P_S 0.23041f
C1515 HS_N_8 HS_N_0 0.03911f
C1516 FS_N_OUT DIV_ENABLE 0.15376f
C1517 PULLUP_P PULLUP_P_BLEED_2 0.14463f
C1518 HS_P_11 PULLDOWN_N_R 0.07466f
C1519 DIV_N PULLDOWN_N_R 0.04202f
C1520 PULLUP_P_OUT HS_N_3 0.02404f
C1521 HS_N_11 TERM_GATE_N 0.04856f
C1522 DIV_P FS_LOW_P 2.36145f
C1523 HS_PBIAS FS_P_BLEED_5 0.09926f
C1524 HS_P_8 HS_P_13 0.05624f
C1525 TERM_P_R PULLUP_N_BLEED_5 0
C1526 FS_N_WELL TERM_N_R 1.67635f
C1527 HS_P_4 PULLDOWN_N_R 0.07217f
C1528 HS_P_8 PAD_P 1.09993f
C1529 TERM_P_R DIV_LOW_P 0.00106f
C1530 HS_P_13 HS_N_7 0.02404f
C1531 PULLUP_P_WELL HS_N_13 0.18668f
C1532 HS_N_12 HS_N_3 0.06413f
C1533 HS_P PULLUP_P_OUT 0.02404f
C1534 PULLUP_P_BLEED_6 HS_N_0 0.02492f
C1535 PAD_P HS_N_7 0.03829f
C1536 FS_LOW_N FS_N_OUT 0.26651f
C1537 HS_P_6 PAD_N 0.31264f
C1538 PULLDOWN_P TERM_OR_N_S 0.12757f
C1539 PULLDOWN_P FS_N_BLEED_2 0.07407f
C1540 PULLUP_P_BLEED_4 PULLUP_P_BLEED_3 3.81017f
C1541 HS_N_9 HS_N_0 0.03911f
C1542 HS_P HS_N_12 0.78589f
C1543 FS_P_BLEED_2 VCM_LOW_OK 0.0381f
C1544 PULLUP_P_OUT PULLUP_P_WELL 32.0321f
C1545 PULLUP_N_OUT PULLUP_P_BLEED_0 0.09268f
C1546 PULLUP_N_OUT HS_P_12 0.03006f
C1547 PULLUP_P_BLEED_5 FS_HIGH_P 0.03577f
C1548 FS_P_OUT PULLUP_N_OUT 0.573f
C1549 BYPASS_ENABLE FS_P_BLEED_2 0.00766f
C1550 PULLUP_N_OUT PULLDOWN_P 0.07847f
C1551 PULLUP_P_BLEED_4 HS_N_3 0.03489f
C1552 HS_N_12 PULLUP_P_WELL 0.19366f
C1553 PULLDOWN_P TERM_GATE_N 0.17903f
C1554 TERM_P_R HS_N_10 0.06034f
C1555 HS_P_13 PAD_N 0.16938f
C1556 FS_N_BLEED_3 FS_N_GATE 0.1926f
C1557 PAD_N PAD_P 55.5603f
C1558 PULLUP_P_BLEED_4 HS_P 0.03489f
C1559 HS_N FS_P_WELL 40.9531f
C1560 HS_N TERM_VCM 0.21161f
C1561 FS_LOW_P PULLUP_N_BLEED_1 0.06271f
C1562 HS_N_11 TERM_ENABLE 0.0483f
C1563 HS_PBIAS PULLUP_N_BLEED_1 0.04828f
C1564 FS_LOW_P HS_N_13 0.08505f
C1565 FS_P_GATE HS_N_7 1.02059f
C1566 PULLUP_P_GATE TERM_VCM 0.16966f
C1567 PULLUP_P_BLEED_4 PULLUP_P_WELL 0.00257f
C1568 FS_HIGH_P FS_P_BLEED_2 0.16613f
C1569 VDD HS_N_10 5.34851f
C1570 HS_PBIAS HS_N_13 4.9299f
C1571 HS_N_11 HS_N_5 0
C1572 HS_N_1 TERM_GATE_N_BLEED_1 0.03489f
C1573 DIV_N FS_P_WELL 0.86039f
C1574 HS_N FS_N_BLEED_6 0.06151f
C1575 HS_N_4 HS_P_3 0.00972f
C1576 FS_N_OUT PULLDOWN_N_R 0.60822f
C1577 HS_N_4 VCM_LOW_OK 0.03489f
C1578 HS_P_11 TERM_VCM 0.13824f
C1579 DIV_N TERM_VCM 0.7231f
C1580 PULLUP_P_OUT FS_LOW_P 0.06604f
C1581 HS_N PULLUP_N_WELL 0.71566f
C1582 TERM_VCM HS_P_4 0.12461f
C1583 HS_N_0 TERM_OR_P_B 0.07497f
C1584 HS_N_7 HS_P_0 0
C1585 PULLUP_P_OUT HS_PBIAS 0.50651f
C1586 PULLUP_P_BLEED_6 HS_N_10 0.02441f
C1587 PULLUP_P_CONTROL_S TERM_N_R 0.06058f
C1588 HS_N_0 TERM_GATE_P 0.11083f
C1589 PULLUP_N_BLEED_2 PULLUP_N_WELL 0.01138f
C1590 HS_N_12 FS_LOW_P 0.08505f
C1591 HS_P_12 TERM_ENABLE 0.02404f
C1592 TERM_GATE_N_BLEED_0 TERM_OR_N_S 0.00179f
C1593 HS_N_0 HS_P_5 0.03489f
C1594 FS_P_OUT TERM_ENABLE 0.53051f
C1595 PULLDOWN_P TERM_ENABLE 0.03743f
C1596 PULLUP_P_CONTROL_S HS_N_6 0.03489f
C1597 HS_N_12 HS_PBIAS 2.63945f
C1598 HS_N_9 HS_N_10 0.04457f
C1599 PULLDOWN_P PULLUP_N_BLEED_3 0.06517f
C1600 PULLUP_P_BLEED_0 HS_N_5 0
C1601 FS_N_WELL HS_P 2.90098f
C1602 FS_HIGH_N PULLUP_N_BLEED_1 0.16603f
C1603 FS_N_BLEED_3 FS_HIGH_P 0
C1604 FS_P_BLEED_0 HS_N_13 0.06178f
C1605 HS_P_12 HS_N_5 0.06578f
C1606 FS_P_OUT HS_N_5 0.43331f
C1607 HS_N_11 PULLDOWN_P_R 0.02429f
C1608 TERM_GATE_N_BLEED_0 TERM_GATE_N 2.02705f
C1609 PULLDOWN_P HS_N_5 0.05303f
C1610 FS_P_BLEED_0 PULLUP_P_OUT 0.14615f
C1611 PAD_N HS_P_0 0.38312f
C1612 PULLUP_P_BLEED_4 FS_LOW_P 0.06866f
C1613 TERM_P_R FS_N_GATE 0.77376f
C1614 TERM_GATE_N_BLEED_1 HS_N_2 0.03489f
C1615 DIV_P HS_P_6 0.03388f
C1616 PULLUP_P_BLEED_4 HS_PBIAS 0.04828f
C1617 FS_P_BLEED_0 HS_N_12 0.06178f
C1618 TERM_GATE_N_BLEED_2 HS_N_7 0.0525f
C1619 TERM_N_R TERM_OR_N_S 0.13199f
C1620 TERM_GATE_N_BLEED_1 DIV_ENABLE 0.01375f
C1621 TERM_GATE_P DIV_LOW_P 0.00428f
C1622 PULLUP_P_BLEED_0 PULLDOWN_P_R 0.12409f
C1623 PULLUP_N_BLEED_0 TERM_ENABLE 0.11535f
C1624 PULLUP_P HS_N_0 0.05062f
C1625 FS_P_BLEED_3 FS_P_WELL 0.00213f
C1626 HS_P_12 PULLDOWN_P_R 0.02404f
C1627 HS_P_5 DIV_LOW_P 0.00305f
C1628 TERM_P_R VCM_LOW_OK 0.34828f
C1629 HS_N_6 TERM_OR_N_S 0.06686f
C1630 TERM_P_R HS_P_3 0.12136f
C1631 FS_P_OUT PULLDOWN_P_R 0.73833f
C1632 PULLDOWN_P PULLDOWN_P_R 0.59344f
C1633 DIFF_ENABLE DIV_ENABLE 6.75692f
C1634 TERM_OR_N_NS TERM_P_R 0.17892f
C1635 FS_N_OUT FS_P_WELL 0.93247f
C1636 PULLUP_N_OUT TERM_N_R 0.29617f
C1637 HS_N_1 HS_N_11 0.07584f
C1638 TERM_N_R TERM_GATE_N 27.6669f
C1639 DIV_P PAD_P 2.52939f
C1640 FS_N_OUT TERM_VCM 0.46016f
C1641 FS_LOW_N TERM_GATE_N_BLEED_1 0.07127f
C1642 HS_N_10 TERM_OR_P_B 0.0738f
C1643 PULLUP_N_OUT HS_N_6 0.04914f
C1644 VDD FS_N_GATE 24.6159f
C1645 HS_P_7 PULLDOWN_N_R 0.02418f
C1646 HS_N_6 TERM_GATE_N 0.05143f
C1647 FS_LOW_N DIFF_ENABLE 0.25257f
C1648 PULLUP_P_OUT HS_P_10 0.05276f
C1649 HS_N_10 TERM_GATE_P 0.10903f
C1650 TERM_OR_P_NS HS_P_3 0.02846f
C1651 VCM_LOW_OK TERM_OR_P_NS 2.92628f
C1652 DIV_LOW_N HS_N_0 0.06949f
C1653 TERM_GATE_N_BLEED_0 TERM_ENABLE 0.00206f
C1654 HS_N_10 HS_P_5 0.03489f
C1655 HS_N_0 FS_P_BLEED_1 0.06178f
C1656 FS_N_WELL FS_LOW_P 1.41044f
C1657 PULLUP_P_CONTROL_S HS_N_3 0.03489f
C1658 HS_N_12 HS_P_10 0.04371f
C1659 VDD HS_P_3 6.14484f
C1660 VDD VCM_LOW_OK 57.6456f
C1661 FS_N_WELL HS_PBIAS 3.38147f
C1662 HS_N_8 VCM_LOW_OK 0.03589f
C1663 HS_N_8 HS_P_3 0.02404f
C1664 PULLUP_P PULLUP_N_BLEED_5 0.05132f
C1665 TERM_OR_N_NS VDD 0.30741f
C1666 HS_P_12 HS_N_1 0.06335f
C1667 PULLUP_N_OUT PULLUP_N_CONTROL_S 0
C1668 HS_P_8 PAD_N 0.85512f
C1669 HS_N PULLUP_P_BLEED_5 0.1021f
C1670 TERM_P_R FS_HIGH_P 0.01008f
C1671 PULLUP_P_CONTROL_S HS_P 0.03489f
C1672 VDD BYPASS_ENABLE 0.04516f
C1673 HS_N_9 FS_N_GATE 0.00226f
C1674 HS_P_6 HS_N_13 0.05888f
C1675 HS_N_1 PULLDOWN_P 0.04428f
C1676 PULLDOWN_P FS_N_BLEED_4 0.08856f
C1677 TERM_N_R TERM_GATE_P_BLEED_1 0.23767f
C1678 FS_P_OUT HS_N_1 0.44686f
C1679 HS_N_4 TERM_OR_N_B 0.02846f
C1680 TERM_P_R TERM_GATE_P_BLEED_0 0.00257f
C1681 PAD_N HS_N_7 1.7635f
C1682 PULLUP_N_BLEED_6 PULLUP_N_BLEED_5 1.37599f
C1683 FS_P_GATE FS_P_BLEED_5 0.30746f
C1684 PULLUP_P_BLEED_5 PULLUP_P_GATE 0.14759f
C1685 PULLUP_P_CONTROL_S PULLUP_P_WELL 0.38592f
C1686 HS_N_11 HS_N_2 0.03504f
C1687 FS_N_CONTROL_S PULLDOWN_N_R 0.09193f
C1688 HS_N_9 VCM_LOW_OK 0.03624f
C1689 HS_N_9 HS_P_3 0.03089f
C1690 PULLUP_P_BLEED_5 DIV_N 0
C1691 HS_N_0 FS_P_CONTROL_S 0.03296f
C1692 HS_P_13 HS_N_13 0.0245f
C1693 HS_N_11 DIV_ENABLE 0.03161f
C1694 TERM_N_R TERM_ENABLE 0.54729f
C1695 HS_N_12 HS_P_6 0.05906f
C1696 HS_N FS_P_BLEED_2 0.04405f
C1697 TERM_GATE_N_BLEED_1 PULLDOWN_N_R 0.04828f
C1698 PAD_P HS_N_13 0.08152f
C1699 TERM_OR_N_S HS_N_3 0.06488f
C1700 FS_HIGH_N FS_N_WELL 0.63376f
C1701 VDD FS_HIGH_P 0.82668f
C1702 PULLUP_N_OUT PULLUP_P_BLEED_3 0
C1703 DIFF_ENABLE PULLDOWN_N_R 0
C1704 HS_N_6 TERM_ENABLE 0.08996f
C1705 VDD TERM_GATE_P_BLEED_0 0.12131f
C1706 PULLUP_N_OUT HS_P_2 0.07964f
C1707 HS_N_8 TERM_GATE_P_BLEED_0 0
C1708 TERM_N_R HS_N_5 0.05893f
C1709 PULLUP_P_GATE FS_P_BLEED_2 0.00448f
C1710 PULLUP_N_OUT PULLUP_N 0.00105f
C1711 HS_P TERM_OR_N_S 0.09563f
C1712 FS_LOW_N HS_N_11 0.04607f
C1713 HS_P FS_N_BLEED_2 0.09016f
C1714 PULLUP_P_OUT PAD_P 0.43807f
C1715 HS_P_12 HS_N_2 0.06578f
C1716 PULLUP_N_OUT HS_N_3 0.00232f
C1717 FS_P_OUT HS_N_2 0.43576f
C1718 HS_N_6 HS_N_5 0.12117p
C1719 HS_P_9 HS_P_3 0.04194f
C1720 TERM_GATE_N HS_N_3 0.04808f
C1721 HS_P_7 TERM_VCM 0.09615f
C1722 HS_P_13 HS_N_12 0.02465f
C1723 FS_N_BLEED_5 FS_N_GATE 0.25005f
C1724 HS_P_9 VCM_LOW_OK 0.0458f
C1725 DIV_N FS_P_BLEED_2 0.10151f
C1726 HS_N_12 PAD_P 2.18792f
C1727 DIV_LOW_N HS_N_10 0.06178f
C1728 HS_N_0 FS_P_BLEED_6 0.06178f
C1729 HS_N_9 FS_HIGH_P 0.01124f
C1730 HS_N_10 FS_P_BLEED_1 0.06178f
C1731 PULLUP_N_OUT HS_P 0.09364f
C1732 DIV_ENABLE RX_N 0.7437f
C1733 HS_P TERM_GATE_N 0.05933f
C1734 FS_P_OUT DIV_ENABLE 0.0629f
C1735 PULLDOWN_P DIV_ENABLE 0.04428f
C1736 PULLUP_P_CONTROL_S FS_LOW_P 0.08479f
C1737 HS_N_9 TERM_GATE_P_BLEED_0 0.00105f
C1738 HS_N FS_N_BLEED_3 0.11535f
C1739 TERM_P_R TERM_OR_N_B 0.36281f
C1740 PULLUP_N_OUT PULLUP_P_WELL 0.60048f
C1741 PULLUP_P_CONTROL_S HS_PBIAS 0.04828f
C1742 FS_P_GATE HS_N_13 1.01205f
C1743 VCM_LOW_OK TERM_OR_P_B 2.10826f
C1744 TERM_OR_P_B HS_P_3 0.10238f
C1745 HS_N_6 PULLDOWN_P_R 0.02404f
C1746 TERM_GATE_P HS_P_3 0.15659f
C1747 FS_LOW_N PULLDOWN_P 0.08215f
C1748 VCM_LOW_OK TERM_GATE_P 0.20188f
C1749 HS_N HS_N_4 1.43714f
C1750 HS_P_5 HS_P_3 0.03192f
C1751 FS_P_BLEED_4 HS_N_5 0.03392f
C1752 HS_P_5 VCM_LOW_OK 0.03489f
C1753 HS_N_4 PULLUP_P_GATE 0.07211f
C1754 FS_P_GATE PULLUP_P_OUT 1.51304f
C1755 TERM_ENABLE PULLUP_P_BLEED_3 0.11229f
C1756 TERM_VCM FS_N_CONTROL_S 0.0423f
C1757 PULLUP_P_BLEED_5 FS_N_OUT 0.06376f
C1758 HS_N_10 FS_P_CONTROL_S 0.03236f
C1759 TERM_ENABLE HS_P_2 0.06392f
C1760 HS_P_9 TERM_GATE_P_BLEED_0 0.03888f
C1761 FS_P_BLEED_5 HS_N_7 0.06246f
C1762 HS_N_11 PULLDOWN_N_R 0.02404f
C1763 HS_P_11 HS_N_4 0.06606f
C1764 HS_N_4 DIV_N 0.03311f
C1765 VDD TERM_OR_N_B 14.119f
C1766 FS_P_GATE HS_N_12 1.01438f
C1767 PULLUP_N PULLUP_N_BLEED_3 0.18975f
C1768 TERM_GATE_N_BLEED_1 TERM_VCM 0.04283f
C1769 HS_N_8 TERM_OR_N_B 0.02879f
C1770 TERM_ENABLE HS_N_3 0.04808f
C1771 FS_N_BLEED_5 FS_HIGH_P 0
C1772 FS_LOW_P FS_N_BLEED_2 0.14463f
C1773 FS_LOW_P TERM_OR_N_S 0.08194f
C1774 HS_N_4 HS_P_4 0
C1775 HS_N_5 HS_P_2 0.03089f
C1776 HS_N_1 TERM_N_R 0.12593f
C1777 TERM_N_R FS_N_BLEED_4 0.05729f
C1778 PULLUP_P FS_N_GATE 1.05236f
C1779 PULLUP_N_BLEED_4 PULLUP_N_BLEED_5 0.55147f
C1780 FS_P_BLEED_3 FS_P_BLEED_2 1.49098f
C1781 TERM_OR_N_S HS_PBIAS 0.18642f
C1782 HS_P PULLUP_N_BLEED_3 0.11785f
C1783 HS_PBIAS FS_N_BLEED_2 0.09926f
C1784 HS_N_5 HS_N_3 0.00206f
C1785 HS_P TERM_ENABLE 0.05441f
C1786 TERM_VCM TERM_OR_P_S 0.05962f
C1787 HS_N_1 HS_N_6 0.04294f
C1788 TERM_OR_P_B TERM_GATE_P_BLEED_0 0.0048f
C1789 PULLUP_N_OUT FS_LOW_P 0.07132f
C1790 FS_N_OUT FS_P_BLEED_2 0.27889f
C1791 HS_N_12 HS_P_0 0.04378f
C1792 TERM_GATE_P TERM_GATE_P_BLEED_0 4.84915f
C1793 FS_LOW_P TERM_GATE_N 0.04939f
C1794 HS_N_9 TERM_OR_N_B 0.02889f
C1795 PULLUP_P_BLEED_0 PULLDOWN_N_R 0.05779f
C1796 PULLUP_P VCM_LOW_OK 0.07118f
C1797 HS_P HS_N_5 0.87187f
C1798 HS_P_5 TERM_GATE_P_BLEED_0 0.0244f
C1799 HS_P_12 PULLDOWN_N_R 0.02404f
C1800 PULLUP_N_OUT HS_PBIAS 0.80187f
C1801 HS_N_10 FS_P_BLEED_6 0.06178f
C1802 PULLUP_P_WELL TERM_ENABLE 2.3244f
C1803 PULLUP_N_GATE PULLUP_N_BLEED_1 0.18141f
C1804 TERM_GATE_N HS_PBIAS 0.17456f
C1805 DIV_P PAD_N 0.47479f
C1806 FS_P_OUT PULLDOWN_N_R 0.68986f
C1807 PULLDOWN_P PULLDOWN_N_R 87.4701f
C1808 PULLDOWN_P_R HS_P_2 0.07466f
C1809 PULLUP_P_BLEED_1 PULLUP_P_GATE 0.12099f
C1810 TERM_GATE_N_BLEED_2 HS_N_13 0.0525f
C1811 HS_N TERM_P_R 0.28926f
C1812 HS_N_5 PULLUP_P_WELL 0.17988f
C1813 PULLDOWN_P_R HS_N_3 0.02404f
C1814 TERM_P_R PULLUP_N_BLEED_2 0.00257f
C1815 TERM_P_R PULLUP_P_GATE 0.20871f
C1816 FS_HIGH_N FS_N_BLEED_2 0
C1817 FS_P_BLEED_1 VCM_LOW_OK 0.14976f
C1818 FS_P_BLEED_4 HS_N_1 0.02938f
C1819 PULLUP_N_OUT FS_P_BLEED_0 0.11535f
C1820 HS_P PULLDOWN_P_R 0.03048f
C1821 TERM_N_R HS_N_2 0.06245f
C1822 DIV_N TERM_P_R 0
C1823 HS_N_7 HS_N_13 0.09546f
C1824 DIV_LOW_N BYPASS_ENABLE 0.00106f
C1825 HS_P_11 TERM_P_R 0.14852f
C1826 HS_N_6 HS_N_2 0
C1827 FS_HIGH_N PULLUP_N_OUT 0.04377f
C1828 TERM_N_R DIV_ENABLE 0.16935f
C1829 TERM_P_R HS_P_4 0.1254f
C1830 TERM_GATE_N_BLEED_2 HS_N_12 0.05263f
C1831 PULLUP_N_BLEED_0 PULLDOWN_N_R 0
C1832 HS_N_11 FS_P_WELL 1.98339f
C1833 HS_N_11 TERM_VCM 0.12019f
C1834 HS_N VDD 2.62171f
C1835 PULLUP_P_WELL PULLDOWN_P_R 0.54541f
C1836 HS_P_8 PULLUP_P_OUT 0.00135f
C1837 HS_N_6 DIV_ENABLE 0.03089f
C1838 HS_N HS_N_8 2.60585f
C1839 FS_LOW_P TERM_ENABLE 0.2004f
C1840 HS_N_1 HS_P_2 0.00649f
C1841 PULLUP_P_OUT HS_N_7 0.02404f
C1842 VDD PULLUP_N_BLEED_2 0
C1843 VDD PULLUP_P_GATE 16.5757f
C1844 HS_P_11 TERM_OR_P_NS 0.04285f
C1845 HS_N_8 PULLUP_P_GATE 0.07585f
C1846 TERM_ENABLE HS_PBIAS 0.73336f
C1847 FS_LOW_N TERM_N_R 0.19132f
C1848 PULLUP_P_BLEED_6 HS_N 0.05048f
C1849 FS_N_BLEED_1 FS_N_GATE 0.17034f
C1850 HS_N_1 HS_N_3 0.08226f
C1851 HS_N_12 HS_N_7 0.02955f
C1852 HS_PBIAS PULLUP_N_BLEED_3 0.17679f
C1853 DIV_LOW_N FS_HIGH_P 0.16534f
C1854 BYPASS_ENABLE RX_P 4.95631f
C1855 HS_P_4 TERM_OR_P_NS 0.02846f
C1856 a_41005_205505# ESD_RAIL 0.53842f
C1857 HS_N_5 FS_LOW_P 0.08533f
C1858 PAD_N HS_N_13 1.56314f
C1859 PULLUP_P_BLEED_6 PULLUP_P_GATE 3.36504f
C1860 VDD HS_P_11 5.06957f
C1861 FS_LOW_N HS_N_6 0.04574f
C1862 FS_P_BLEED_1 FS_HIGH_P 0
C1863 VDD DIV_N 0.42835f
C1864 DIV_N HS_N_8 0.03311f
C1865 HS_P_11 HS_N_8 0.02857f
C1866 a_53878_204105# a_53878_203545# 0.0346f
C1867 HS_N HS_N_9 5.92574f
C1868 HS_P FS_N_BLEED_4 0.08856f
C1869 PULLUP_N_OUT HS_P_10 0.08961f
C1870 HS_N_5 HS_PBIAS 2.62068f
C1871 HS_P HS_N_1 0.17892f
C1872 HS_P_12 FS_P_WELL 0.00134f
C1873 VDD HS_P_4 4.77123f
C1874 FS_P_BLEED_4 HS_N_2 0.02846f
C1875 HS_N_8 HS_P_4 0.02404f
C1876 HS_P_12 TERM_VCM 0.107f
C1877 FS_P_OUT FS_P_WELL 0.18171p
C1878 FS_P_OUT TERM_VCM 0.38638f
C1879 HS_N_9 PULLUP_P_GATE 0.07724f
C1880 PULLUP_P_OUT PAD_N 0.20199f
C1881 PULLDOWN_P TERM_VCM 0.18548f
C1882 a_41005_203825# ESD_RAIL 0.53823f
C1883 PULLUP_N_OUT HS_P_1 0.05947f
C1884 HS_N_1 PULLUP_P_WELL 0.23015f
C1885 FS_P_BLEED_0 TERM_ENABLE 0.08071f
C1886 PULLUP_P_BLEED_4 HS_N_7 0.03489f
C1887 HS_N_12 PAD_N 1.21768f
C1888 HS_N_9 HS_P_11 0.03103f
C1889 HS_N_9 DIV_N 0.03311f
C1890 FS_LOW_P PULLDOWN_P_R 0.06539f
C1891 FS_HIGH_N TERM_ENABLE 0.01513f
C1892 HS_N_2 HS_P_2 0.06704f
C1893 PULLDOWN_P FS_N_BLEED_6 0.04811f
C1894 HS_N_9 HS_P_4 0.03089f
C1895 FS_P_BLEED_0 HS_N_5 0.06178f
C1896 HS_PBIAS PULLDOWN_P_R 0.50594f
C1897 PULLUP_P TERM_OR_N_B 0.13572f
C1898 PULLDOWN_P PULLUP_N_WELL 0.43199f
C1899 HS_N HS_P_9 0.12189f
C1900 FS_P_CONTROL_S FS_HIGH_P 0.47537f
C1901 FS_N_OUT TERM_P_R 0.34518f
C1902 HS_N_2 HS_N_3 0.12299p
C1903 PULLUP_N_OUT HS_P_6 0.02846f
C1904 TERM_N_R PULLDOWN_N_R 0.22255f
C1905 TERM_ENABLE PULLDOWN_N 0.06103f
C1906 FS_N_BLEED_1 FS_HIGH_P 0
C1907 PULLUP_N_BLEED_0 TERM_VCM 0.13459f
C1908 HS_N FS_N_BLEED_5 0.11535f
C1909 DIV_ENABLE HS_N_3 0.03089f
C1910 HS_P HS_N_2 0.85293f
C1911 HS_P_11 HS_P_9 0.00817f
C1912 HS_N_6 PULLDOWN_N_R 0.06832f
C1913 VDD FS_P_BLEED_3 0.00257f
C1914 HS_N TERM_OR_P_B 0.1311f
C1915 HS_P_9 HS_P_4 0.042f
C1916 HS_P_13 PULLUP_N_OUT 0.02868f
C1917 HS_P DIV_ENABLE 0.03818f
C1918 PULLUP_P_WELL HS_N_2 0.17784f
C1919 TERM_ENABLE HS_P_10 0.0768f
C1920 HS_N TERM_GATE_P 0.17562f
C1921 FS_P_BLEED_0 PULLDOWN_P_R 0.10124f
C1922 FS_N_BLEED_4 FS_LOW_P 0.08101f
C1923 HS_N HS_P_5 0.39228f
C1924 PULLUP_N_OUT PAD_P 0.11127f
C1925 FS_LOW_N HS_N_3 0.04574f
C1926 HS_N_1 FS_LOW_P 0.08505f
C1927 VDD FS_N_OUT 11.7636f
C1928 PULLUP_N_BLEED_0 PULLUP_N_WELL 2.56376f
C1929 TERM_ENABLE HS_P_1 0.02404f
C1930 HS_N_1 HS_PBIAS 9.60149f
C1931 FS_N_BLEED_4 HS_PBIAS 0.08856f
C1932 HS_N_5 HS_P_10 0.03089f
C1933 HS_P_11 TERM_OR_P_B 0.11938f
C1934 DIV_N TERM_OR_P_B 0.00135f
C1935 PULLUP_N_CONTROL_S PULLDOWN_N_R 0.03764f
C1936 PULLUP_P_WELL DIV_ENABLE 0.01343f
C1937 FS_LOW_N HS_P 0.04574f
C1938 TERM_GATE_N_BLEED_0 TERM_VCM 0.11862f
C1939 PULLUP_P_BLEED_2 VCM_LOW_OK 0.01462f
C1940 DIV_N TERM_GATE_P 0.00178f
C1941 HS_P_4 TERM_OR_P_B 0.10189f
C1942 HS_P_11 TERM_GATE_P 0.1736f
C1943 HS_N_5 HS_P_1 0.03097f
C1944 a_41005_204945# ESD_RAIL 0.53823f
C1945 HS_N_0 DIV_LOW_P 0.00585f
C1946 FS_P_BLEED_5 HS_N_13 0.06178f
C1947 HS_P_11 HS_P_5 0.03881f
C1948 DIV_N HS_P_5 0.01203f
C1949 HS_P_4 TERM_GATE_P 0.15627f
C1950 HS_N_9 FS_N_OUT 0.06167f
C1951 HS_P_5 HS_P_4 32.9896f
C1952 TERM_ENABLE HS_P_6 0.02404f
C1953 PULLUP_P_BLEED_5 HS_N_11 0.05266f
C1954 FS_P_BLEED_0 HS_N_1 0.06178f
C1955 HS_N_4 TERM_GATE_N_BLEED_1 0.03489f
C1956 HS_P_10 PULLDOWN_P_R 0.07466f
C1957 PULLUP_P_OUT TERM_GATE_P_BLEED_2 0.04242f
C1958 PULLUP_N_OUT FS_P_GATE 1.25039f
C1959 FS_HIGH_N FS_N_BLEED_4 0
C1960 HS_N_5 HS_P_6 0.05828f
C1961 HS_N_12 FS_P_BLEED_5 0.06178f
C1962 FS_LOW_P HS_N_2 0.21255f
C1963 HS_N_0 HS_N_10 2.19009f
C1964 HS_P_2 PULLDOWN_N_R 0.07217f
C1965 TERM_N_R FS_P_WELL 1.56981f
C1966 HS_P_7 TERM_P_R 0.08343f
C1967 FS_LOW_P FS_N_BLEED_0 0.83515f
C1968 PULLDOWN_P_R HS_P_1 0.08595f
C1969 TERM_N_R TERM_VCM 17.4845f
C1970 PULLUP_P PULLUP_P_GATE 3.89342f
C1971 PULLUP_N PULLDOWN_N_R 0.09205f
C1972 HS_N_2 HS_PBIAS 2.89631f
C1973 HS_N_6 FS_P_WELL 1.93035f
C1974 HS_P_13 TERM_ENABLE 0.02404f
C1975 HS_N_3 PULLDOWN_N_R 0.02404f
C1976 HS_N_6 TERM_VCM 0.13016f
C1977 PULLUP_P_BLEED_0 PULLUP_P_BLEED_5 0
C1978 HS_N_11 FS_P_BLEED_2 0.03472f
C1979 FS_LOW_P DIV_ENABLE 0.10858f
C1980 a_41005_203545# ESD_RAIL 96.5489f
C1981 PULLUP_N_OUT HS_P_0 0.09237f
C1982 PULLDOWN_P PULLUP_P_BLEED_5 0
C1983 HS_PBIAS DIV_ENABLE 0.06119f
C1984 HS_P_13 HS_N_5 0.05493f
C1985 HS_P PULLDOWN_N_R 0.04198f
C1986 HS_N DIV_LOW_N 0.08856f
C1987 TERM_N_R FS_N_BLEED_6 0.06105f
C1988 HS_P_7 TERM_OR_P_NS 0.02846f
C1989 HS_N FS_P_BLEED_1 0.08043f
C1990 HS_N_5 PAD_P 0.34243f
C1991 FS_LOW_N FS_LOW_P 93.9795f
C1992 TERM_N_R PULLUP_N_WELL 0.28431f
C1993 HS_P_6 PULLDOWN_P_R 0.02404f
C1994 PULLUP_P_CONTROL_S HS_N_7 0.03489f
C1995 PULLUP_P_WELL PULLDOWN_N_R 0.41482f
C1996 VDD HS_P_7 4.96081f
C1997 FS_N_OUT TERM_OR_P_B 0.05082f
C1998 FS_P_BLEED_1 PULLUP_P_GATE 0
C1999 HS_N_1 HS_P_10 0.0348f
C2000 FS_LOW_N HS_PBIAS 0.34931f
C2001 HS_P_7 HS_N_8 0.09182f
C2002 FS_P_BLEED_0 HS_N_2 0.06178f
C2003 TERM_P_R FS_N_CONTROL_S 0.0414f
C2004 FS_N_OUT TERM_GATE_P 0.1125f
C2005 DIV_LOW_N DIV_N 5.26099f
C2006 FS_P_OUT FS_P_BLEED_2 0
C2007 HS_N_10 DIV_LOW_P 0.00259f
C2008 HS_N_1 HS_P_1 0.09066f
C2009 FS_HIGH_N FS_N_BLEED_0 0.00964f
C2010 FS_N_OUT HS_P_5 0.06167f
C2011 HS_P_13 PULLDOWN_P_R 0.02404f
C2012 PULLUP_P_OUT HS_N_13 0.02464f
C2013 FS_P_GATE TERM_ENABLE 0.94589f
C2014 PULLDOWN_P_R PAD_P 2.92129f
C2015 TERM_P_R TERM_GATE_N_BLEED_1 0.04766f
C2016 FS_HIGH_N DIV_ENABLE 3.74927f
C2017 TERM_P_R DIFF_ENABLE 2.11502f
C2018 PULLUP_N_OUT PULLUP_N_GATE 18.1444f
C2019 PULLUP_N_CONTROL_S PULLUP_N_WELL 0.08371f
C2020 HS_N FS_P_CONTROL_S 0.04342f
C2021 HS_N_9 HS_P_7 0.0401f
C2022 HS_N_4 HS_N_11 0
C2023 HS_N_12 HS_N_13 0.13526p
C2024 PULLUP_N_OUT TERM_GATE_N_BLEED_2 0.09196f
C2025 TERM_P_R TERM_OR_P_S 2.01371f
C2026 PULLUP_P_BLEED_3 TERM_VCM 0.09096f
C2027 FS_P_GATE HS_N_5 1.01668f
C2028 HS_N_1 HS_P_6 0.06023f
C2029 TERM_GATE_N_BLEED_2 TERM_GATE_N 0.40639f
C2030 HS_N FS_N_BLEED_1 0.07097f
C2031 TERM_OR_N_S HS_N_7 0.06826f
C2032 VDD FS_N_CONTROL_S 0.70784f
C2033 FS_HIGH_N FS_LOW_N 0.04574f
C2034 ESD_RAIL m2_42279_196800# 5.47988f
C2035 DIV_N RX_P 0.72665f
C2036 TERM_VCM HS_P_2 0.09615f
C2037 TERM_ENABLE HS_P_0 0.03037f
C2038 HS_N_3 FS_P_WELL 1.91556f
C2039 HS_N_2 HS_P_10 0.03089f
C2040 TERM_VCM HS_N_3 0.12454f
C2041 HS_P_8 PULLUP_N_OUT 0.0429f
C2042 PULLUP_P_OUT HS_N_12 0.02482f
C2043 VDD TERM_GATE_N_BLEED_1 0.45188f
C2044 FS_N_BLEED_3 PULLDOWN_P 0.09712f
C2045 a_53878_204105# a_53878_204665# 0.0346f
C2046 FS_LOW_P PULLDOWN_N_R 0.0629f
C2047 PULLUP_N_OUT HS_N_7 0.05812f
C2048 PULLUP_P FS_N_OUT 0.46602f
C2049 TERM_GATE_N_BLEED_1 HS_N_8 0.03489f
C2050 TERM_GATE_N HS_N_7 0.05242f
C2051 TERM_OR_P_NS TERM_OR_P_S 0.00736f
C2052 HS_N_5 HS_P_0 0.03733f
C2053 PULLUP_P_BLEED_4 HS_N_13 0.03489f
C2054 HS_PBIAS PULLDOWN_N_R 0.77848f
C2055 HS_N_2 HS_P_1 0.09798f
C2056 HS_P_7 HS_P_9 0.00206f
C2057 HS_P_13 HS_N_1 0.12155f
C2058 HS_P_12 HS_N_4 0.07181f
C2059 HS_P FS_P_WELL 2.03508f
C2060 HS_P TERM_VCM 0.23967f
C2061 HS_N FS_P_BLEED_6 0.08043f
C2062 HS_N_0 HS_P_3 0.02686f
C2063 HS_N_1 PAD_P 0.48214f
C2064 FS_P_OUT HS_N_4 0.43331f
C2065 FS_P_GATE PULLDOWN_P_R 1.53341f
C2066 HS_N_0 VCM_LOW_OK 0.03489f
C2067 VDD TERM_OR_P_S 4.39982f
C2068 PULLUP_N PULLUP_N_WELL 0.11608f
C2069 FS_P_BLEED_6 PULLUP_P_GATE 0.06116f
C2070 PULLUP_P_WELL TERM_VCM 0.38283f
C2071 FS_P_BLEED_3 FS_P_BLEED_1 0
C2072 HS_N_9 TERM_GATE_N_BLEED_1 0.03489f
C2073 DIV_LOW_N FS_N_OUT 0.11535f
C2074 HS_P FS_N_BLEED_6 0.04811f
C2075 HS_N_2 HS_P_6 0.05876f
C2076 HS_P_7 TERM_OR_P_B 0.10117f
C2077 FS_N_OUT FS_P_BLEED_1 0.14463f
C2078 PULLUP_N_GATE TERM_ENABLE 0.23036f
C2079 PULLUP_P_BLEED_4 HS_N_12 0.03489f
C2080 PULLUP_N_OUT PAD_N 1.29226f
C2081 PULLUP_N_GATE PULLUP_N_BLEED_3 0.08138f
C2082 HS_P PULLUP_N_WELL 0.29195f
C2083 PULLUP_N_BLEED_4 PULLUP_N_BLEED_2 0.00326f
C2084 FS_P_BLEED_0 PULLDOWN_N_R 0.10124f
C2085 PULLDOWN_P_R HS_P_0 0.03037f
C2086 HS_P_7 TERM_GATE_P 0.15508f
C2087 TERM_GATE_N_BLEED_2 TERM_ENABLE 0.07928f
C2088 HS_P_7 HS_P_5 0.03078f
C2089 TERM_P_R HS_N_11 0.05996f
C2090 FS_HIGH_N PULLDOWN_N_R 0.03743f
C2091 HS_N_6 PULLUP_P_BLEED_5 0.0525f
C2092 TERM_GATE_N_BLEED_2 HS_N_5 0.0525f
C2093 HS_N_0 FS_HIGH_P 0
C2094 PULLUP_P_BLEED_1 PULLUP_P_BLEED_0 1.16396f
C2095 HS_P_13 HS_N_2 0.07762f
C2096 FS_N_WELL HS_N_13 0.02097f
C2097 HS_P_8 TERM_ENABLE 0.02404f
C2098 FS_P_GATE HS_N_1 1.01946f
C2099 HS_N_2 PAD_P 1.25659f
C2100 TERM_ENABLE HS_N_7 0.10332f
C2101 FS_N_OUT RX_P 0.01284f
C2102 PULLDOWN_N PULLDOWN_N_R 5.82803f
C2103 FS_N_OUT FS_P_CONTROL_S 0.00663f
C2104 VDD HS_N_11 6.23318f
C2105 BYPASS_ENABLE DIV_LOW_P 0
C2106 TERM_N_R FS_P_BLEED_2 0.06105f
C2107 HS_P_12 TERM_P_R 0.11066f
C2108 FS_LOW_P FS_P_WELL 1.90656f
C2109 PAD_P DIV_ENABLE 0.14682f
C2110 HS_N_10 FS_N_GATE 0.0213f
C2111 FS_LOW_P TERM_VCM 0.24716f
C2112 HS_N_5 HS_N_7 0.07798f
C2113 FS_P_OUT TERM_P_R 0.43231f
C2114 PULLUP_P_GATE PULLUP_P_BLEED_2 0.20496f
C2115 PULLDOWN_P TERM_P_R 0.13388f
C2116 HS_N_1 HS_P_0 0.04113f
C2117 HS_N_6 FS_P_BLEED_2 0.03472f
C2118 HS_PBIAS FS_P_WELL 3.39639f
C2119 HS_PBIAS TERM_VCM 0.8645f
C2120 FS_N_WELL HS_N_12 0.02014f
C2121 HS_P_10 PULLDOWN_N_R 0.07466f
C2122 HS_N_10 HS_P_3 0.02545f
C2123 PULLUP_P_BLEED_6 HS_N_11 0.02434f
C2124 HS_N_10 VCM_LOW_OK 0.03489f
C2125 HS_P_12 TERM_OR_P_NS 0.03931f
C2126 HS_P_1 PULLDOWN_N_R 0.06544f
C2127 FS_LOW_P FS_N_BLEED_6 0.18143f
C2128 TERM_OR_P_B TERM_OR_P_S 1.83456f
C2129 FS_P_BLEED_3 FS_P_BLEED_6 0.06069f
C2130 VDD PULLUP_P_BLEED_0 0.0048f
C2131 FS_LOW_P PULLUP_N_WELL 0.22587f
C2132 HS_N_9 HS_N_11 0.03511f
C2133 VDD HS_P_12 4.78775f
C2134 HS_PBIAS FS_N_BLEED_6 0.04811f
C2135 PULLUP_P_BLEED_0 HS_N_8 0
C2136 HS_P_8 PULLDOWN_P_R 0.08554f
C2137 a_41005_203545# a_42245_162628# 0.0135f
C2138 FS_P_GATE HS_N_2 1.01182f
C2139 VDD FS_P_OUT 10.8417f
C2140 HS_N_5 PAD_N 1.1645f
C2141 HS_P_12 HS_N_8 0.06335f
C2142 PULLDOWN_P_R HS_N_7 0.02404f
C2143 HS_PBIAS PULLUP_N_WELL 0.46702f
C2144 VDD PULLDOWN_P 1.68509f
C2145 FS_N_OUT FS_P_BLEED_6 0.04877f
C2146 PULLUP_P_BLEED_5 PULLUP_P_BLEED_3 0
C2147 FS_P_OUT HS_N_8 0.43367f
C2148 FS_P_BLEED_0 FS_P_WELL 4.87896f
C2149 PULLDOWN_P HS_N_8 0.04428f
C2150 FS_P_BLEED_0 TERM_VCM 0.0189f
C2151 TERM_P_R PULLUP_N_BLEED_0 0.1115f
C2152 HS_P_6 PULLDOWN_N_R 0.02414f
C2153 FS_P_GATE DIV_ENABLE 0.00424f
C2154 PULLUP_P_BLEED_5 HS_N_3 0.0525f
C2155 PULLUP_P_BLEED_6 PULLDOWN_P 0.00512f
C2156 HS_N_4 TERM_N_R 0.05893f
C2157 HS_N_0 TERM_OR_N_B 0.03206f
C2158 PULLUP_P FS_N_CONTROL_S 0.1046f
C2159 TERM_GATE_N_BLEED_2 HS_N_1 0.05286f
C2160 HS_N_9 PULLUP_P_BLEED_0 0.00105f
C2161 HS_N_2 HS_P_0 0.03722f
C2162 PULLUP_N_OUT FS_P_BLEED_5 0
C2163 HS_N_10 FS_HIGH_P 0
C2164 HS_N_9 HS_P_12 0.06578f
C2165 HS_N_4 HS_N_6 0.07075f
C2166 PULLUP_P_CONTROL_S HS_N_13 0.03489f
C2167 HS_P PULLUP_P_BLEED_5 0.0525f
C2168 FS_P_OUT HS_N_9 0.43377f
C2169 PULLUP_P TERM_GATE_N_BLEED_1 0.05462f
C2170 PULLDOWN_P_R PAD_N 0.0844f
C2171 TERM_VCM PULLDOWN_N 0.0428f
C2172 FS_HIGH_N FS_N_BLEED_6 0.1661f
C2173 PULLUP_P DIFF_ENABLE 0.0661f
C2174 HS_P_13 PULLDOWN_N_R 0.02404f
C2175 FS_HIGH_N PULLUP_N_WELL 0.14189f
C2176 VDD PULLUP_N_BLEED_0 0.77784f
C2177 PAD_P PULLDOWN_N_R 1.40429f
C2178 PULLUP_P_BLEED_5 PULLUP_P_WELL 0
C2179 HS_N_1 HS_N_7 0.0739f
C2180 TERM_P_R TERM_GATE_N_BLEED_0 0.10627f
C2181 PULLUP_P_CONTROL_S PULLUP_P_OUT 0.01177f
C2182 FS_P_BLEED_2 HS_N_3 0.03472f
C2183 HS_P_10 TERM_VCM 0.13491f
C2184 HS_N_11 TERM_OR_P_B 0.07338f
C2185 HS_P FS_P_BLEED_2 0.03472f
C2186 HS_N_11 TERM_GATE_P 0.10852f
C2187 PULLUP_P_CONTROL_S HS_N_12 0.03489f
C2188 TERM_VCM HS_P_1 0.15005f
C2189 HS_N_11 HS_P_5 0.03489f
C2190 HS_N_4 FS_P_BLEED_4 0.03258f
C2191 TERM_GATE_P_BLEED_1 TERM_GATE_P_BLEED_2 1.09058f
C2192 TERM_GATE_N_BLEED_2 HS_N_2 0.0525f
C2193 TERM_OR_N_S HS_N_13 0.06335f
C2194 PULLUP_P_WELL FS_P_BLEED_2 0.00542f
C2195 HS_N_1 PAD_N 1.13339f
C2196 PULLUP_N_GATE DIV_ENABLE 0
C2197 VDD TERM_GATE_N_BLEED_0 0.97216f
C2198 TERM_GATE_N_BLEED_2 DIV_ENABLE 0
C2199 PULLUP_N_OUT PULLUP_N_BLEED_1 0.00305f
C2200 TERM_P_R TERM_N_R 35.4953f
C2201 PULLDOWN_P FS_N_BLEED_5 0.08856f
C2202 HS_P_12 TERM_OR_P_B 0.13059f
C2203 VCM_LOW_OK HS_P_3 0.09096f
C2204 FS_P_GATE PULLDOWN_N_R 1.43346f
C2205 FS_P_OUT TERM_OR_P_B 0.16122f
C2206 TERM_OR_N_NS VCM_LOW_OK 2.03284f
C2207 HS_P_6 TERM_VCM 0.09615f
C2208 HS_N_4 HS_P_2 0.00376f
C2209 TERM_ENABLE TERM_GATE_P_BLEED_2 0.07306f
C2210 HS_P_12 TERM_GATE_P 0.16452f
C2211 PULLUP_N_OUT HS_N_13 0.04377f
C2212 HS_N_6 TERM_P_R 0.05893f
C2213 HS_N_2 HS_N_7 0.02926f
C2214 FS_P_OUT TERM_GATE_P 0.22814f
C2215 HS_N_10 TERM_OR_N_B 0.03027f
C2216 TERM_GATE_N HS_N_13 0.04808f
C2217 FS_LOW_N PULLUP_N_GATE 0.09329f
C2218 HS_P_12 HS_P_5 0.03887f
C2219 PULLUP_P_BLEED_5 FS_LOW_P 0.0781f
C2220 HS_N HS_N_0 0.13402p
C2221 HS_N_5 FS_P_BLEED_5 0.06219f
C2222 HS_N_4 HS_N_3 0.1223p
C2223 FS_N_BLEED_3 HS_P 0.08856f
C2224 FS_P_OUT HS_P_5 0.05462f
C2225 FS_LOW_N TERM_GATE_N_BLEED_2 0.0839f
C2226 PULLUP_P_BLEED_5 HS_PBIAS 0.07928f
C2227 HS_N_12 TERM_OR_N_S 0.06335f
C2228 TERM_N_R TERM_OR_P_NS 0.1011f
C2229 DIV_ENABLE HS_N_7 0.03089f
C2230 HS_N_0 PULLUP_P_GATE 0.07594f
C2231 PULLUP_N_OUT PULLUP_P_OUT 0.17397f
C2232 FS_N_GATE FS_HIGH_P 0.08476f
C2233 HS_P_13 FS_P_WELL 0.19945f
C2234 HS_P_0 PULLDOWN_N_R 0.03037f
C2235 HS_P_13 TERM_VCM 0.09664f
C2236 a_43813_189064# ESD_RAIL 4.89902f
C2237 HS_N_4 HS_P 0.32519f
C2238 VDD TERM_N_R 6.61679f
C2239 HS_N_6 TERM_OR_P_NS 0.00351f
C2240 TERM_VCM PAD_P 0.0027f
C2241 DIV_N HS_N_0 0.04097f
C2242 PULLUP_N_OUT HS_N_12 0.01368f
C2243 HS_N_8 TERM_N_R 0.11657f
C2244 HS_N_12 TERM_GATE_N 0.04844f
C2245 FS_LOW_N HS_N_7 0.04574f
C2246 VDD HS_N_6 6.53266f
C2247 HS_N_4 PULLUP_P_WELL 0.18371f
C2248 HS_N_2 PAD_N 1.16258f
C2249 HS_N_6 HS_N_8 0.04946f
C2250 FS_LOW_P FS_P_BLEED_2 0.07139f
C2251 TERM_GATE_P_BLEED_0 HS_P_3 0.02464f
C2252 FS_P_BLEED_5 PULLDOWN_P_R 0.08553f
C2253 HS_PBIAS FS_P_BLEED_2 0.04811f
C2254 PULLUP_P PULLUP_P_BLEED_0 0.85278f
C2255 DIV_LOW_N HS_N_11 0.06178f
C2256 PAD_N DIV_ENABLE 0.03382f
C2257 PULLUP_P_BLEED_6 HS_N_6 0.03306f
C2258 BYPASS_ENABLE FS_HIGH_P 0
C2259 HS_N_11 FS_P_BLEED_1 0.06178f
C2260 PULLUP_P_BLEED_1 PULLUP_P_BLEED_3 0.10974f
C2261 HS_N_9 TERM_N_R 0.05948f
C2262 HS_N DIV_LOW_P 0.06611f
C2263 TERM_ENABLE PULLUP_N_BLEED_1 0.06151f
C2264 PULLUP_P_OUT TERM_GATE_P_BLEED_1 0.14929f
C2265 PULLUP_N_BLEED_3 PULLUP_N_BLEED_1 0.00153f
C2266 PULLUP_N_BLEED_2 PULLUP_N_BLEED_5 0.00252f
C2267 PULLUP_P_BLEED_4 PULLUP_N_OUT 0.05472f
C2268 HS_N_9 HS_N_6 0.04101f
C2269 VDD PULLUP_N_CONTROL_S 0.45153f
C2270 TERM_P_R PULLUP_P_BLEED_3 0.11141f
C2271 TERM_ENABLE HS_N_13 0.08853f
C2272 TERM_P_R HS_P_2 0.08491f
C2273 PULLUP_N_GATE PULLDOWN_N_R 1.24845f
C2274 TERM_P_R PULLUP_N 0.18126f
C2275 TERM_GATE_N_BLEED_2 PULLDOWN_N_R 0.07928f
C2276 FS_P_GATE FS_P_WELL 0.25901p
C2277 VDD FS_P_BLEED_4 0.00257f
C2278 FS_P_BLEED_0 FS_P_BLEED_2 0.00855f
C2279 HS_N_5 HS_N_13 0.10387f
C2280 TERM_P_R HS_N_3 0.05893f
C2281 FS_P_GATE TERM_VCM 0.5858f
C2282 FS_P_BLEED_4 HS_N_8 0.04285f
C2283 FS_N_BLEED_3 FS_LOW_P 0.10387f
C2284 DIV_N DIV_LOW_P 0.89345f
C2285 PULLUP_P_OUT TERM_ENABLE 11.5152f
C2286 DIV_LOW_N PULLDOWN_P 0.08775f
C2287 HS_N HS_N_10 3.84913f
C2288 HS_N_1 FS_P_BLEED_5 0.06178f
C2289 FS_N_BLEED_3 HS_PBIAS 0.08856f
C2290 HS_P_8 PULLDOWN_N_R 0.06544f
C2291 HS_N_11 FS_P_CONTROL_S 0.03234f
C2292 HS_P TERM_P_R 0.1669f
C2293 HS_N_12 TERM_ENABLE 0.04825f
C2294 HS_N_4 FS_LOW_P 0.08505f
C2295 TERM_OR_P_NS HS_P_2 0.02846f
C2296 PULLUP_P_BLEED_1 PULLUP_P_WELL 0.12285f
C2297 FS_P_BLEED_3 HS_N_0 0
C2298 HS_N_7 PULLDOWN_N_R 0.06832f
C2299 PULLUP_P_OUT HS_N_5 0.02404f
C2300 PULLUP_P PULLUP_N_BLEED_0 0.10442f
C2301 a_53878_204105# ESD_RAIL 0.53942f
C2302 HS_N_10 PULLUP_P_GATE 0.07414f
C2303 FS_N_WELL FS_N_BLEED_2 0
C2304 VDD PULLUP_P_BLEED_3 0.52408f
C2305 HS_N_3 TERM_OR_P_NS 0.00153f
C2306 HS_N_4 HS_PBIAS 1.07268f
C2307 TERM_VCM HS_P_0 0.19537f
C2308 VDD HS_P_2 5.70329f
C2309 HS_N_8 HS_P_2 0.02404f
C2310 HS_N_9 FS_P_BLEED_4 0.0479f
C2311 DIV_N HS_N_10 0.03311f
C2312 FS_N_OUT HS_N_0 0.06167f
C2313 TERM_P_R PULLUP_P_WELL 0.32267f
C2314 FS_N_BLEED_5 TERM_N_R 0.11444f
C2315 a_53878_206345# a_53878_205785# 0.0346f
C2316 HS_P_11 HS_N_10 0.00351f
C2317 HS_N_12 HS_N_5 0
C2318 VDD PULLUP_N 0.01619f
C2319 PULLUP_N_OUT FS_N_WELL 2.20637f
C2320 VCM_LOW_OK TERM_OR_N_B 4.35323f
C2321 VDD HS_N_3 5.42295f
C2322 PULLDOWN_P_R HS_N_13 0.02404f
C2323 HS_P TERM_OR_P_NS 0.04056f
C2324 TERM_N_R TERM_OR_P_B 1.12426f
C2325 FS_P_OUT RX_P 0.01238f
C2326 RX_P RX_N 12.5825f
C2327 TERM_OR_N_NS TERM_OR_N_B 0.94577f
C2328 HS_N_8 HS_N_3 0
C2329 PULLUP_P_BLEED_4 TERM_ENABLE 0.06028f
C2330 VDD HS_P 1.70325f
C2331 HS_N_6 TERM_OR_P_B 0.07211f
C2332 FS_P_OUT FS_P_CONTROL_S 0
C2333 TERM_N_R TERM_GATE_P 1.39719f
C2334 PULLUP_P_BLEED_6 HS_N_3 0.02795f
C2335 HS_N_11 FS_P_BLEED_6 0.06178f
C2336 FS_HIGH_N FS_N_BLEED_3 0
C2337 HS_P HS_N_8 0.59635f
C2338 HS_N_6 TERM_GATE_P 0.11785f
C2339 PAD_N PULLDOWN_N_R 4.48191f
C2340 HS_N_9 HS_P_2 0.03089f
C2341 PULLUP_P_OUT PULLDOWN_P_R 0.10481f
C2342 FS_P_BLEED_0 HS_N_4 0.06178f
C2343 HS_N_2 FS_P_BLEED_5 0.06178f
C2344 PULLUP_P_BLEED_4 HS_N_5 0.03489f
C2345 a_41005_203825# a_41005_204385# 0.0346f
C2346 HS_N_6 HS_P_5 0.1437f
C2347 PULLUP_P_BLEED_6 HS_P 0.10214f
C2348 VDD PULLUP_P_WELL 29.4887f
C2349 HS_N_9 HS_N_3 0.00333f
C2350 HS_N_12 PULLDOWN_P_R 0.02424f
C2351 HS_N_8 PULLUP_P_WELL 0.19877f
C2352 PULLUP_N_GATE TERM_VCM 0.25356f
C2353 TERM_GATE_N_BLEED_2 TERM_VCM 0.01503f
C2354 HS_N_9 HS_P 0.12031p
C2355 a_44789_189064# ESD_RAIL 13.9519f
C2356 HS_N_1 HS_N_13 0.09085f
C2357 DIV_P DIV_ENABLE 4.76769f
C2358 FS_N_OUT DIV_LOW_P 0.05525f
C2359 TERM_P_R FS_LOW_P 0.25019f
C2360 HS_P_9 HS_P_2 0.0419f
C2361 PULLUP_N_GATE FS_N_BLEED_6 0.00548f
C2362 PULLUP_P_BLEED_4 PULLDOWN_P_R 0.05462f
C2363 TERM_P_R HS_PBIAS 0.54217f
C2364 HS_P_8 TERM_VCM 0.09671f
C2365 HS_N_9 PULLUP_P_WELL 0.21266f
C2366 FS_P_BLEED_3 HS_N_10 0
C2367 PULLUP_P_OUT HS_N_1 0.02599f
C2368 PULLUP_P TERM_N_R 0.50582f
C2369 a_41005_206065# ESD_RAIL 0.57348f
C2370 PULLUP_N_GATE PULLUP_N_WELL 36.3413f
C2371 HS_N_7 FS_P_WELL 1.93951f
C2372 TERM_VCM HS_N_7 0.18446f
C2373 FS_N_WELL TERM_ENABLE 2.56366f
C2374 HS_N FS_N_GATE 2.00434f
C2375 HS_N_4 HS_P_10 0.07706f
C2376 PULLUP_P HS_N_6 0.04377f
C2377 PULLDOWN_P PULLUP_N_BLEED_4 0.08014f
C2378 FS_N_OUT HS_N_10 0.00528f
C2379 PULLUP_N_BLEED_6 TERM_N_R 0.05729f
C2380 FS_LOW_P TERM_OR_P_NS 0.39723f
C2381 HS_P HS_P_9 6.36218f
C2382 HS_N_1 HS_N_12 0.07584f
C2383 HS_N HS_P_3 0.27803f
C2384 TERM_OR_P_B HS_P_2 0.10307f
C2385 HS_N VCM_LOW_OK 0.04122f
C2386 HS_N_4 HS_P_1 0.0586f
C2387 VDD FS_LOW_P 3.96025f
C2388 PULLUP_N_OUT PULLUP_P_CONTROL_S 0.05462f
C2389 HS_N_8 FS_LOW_P 0.08561f
C2390 TERM_GATE_P HS_P_2 0.15718f
C2391 FS_P_BLEED_0 TERM_P_R 0.04596f
C2392 VDD HS_PBIAS 83.4779f
C2393 TERM_OR_P_B HS_N_3 0.07211f
C2394 PULLUP_P_GATE VCM_LOW_OK 0.34939f
C2395 DIV_LOW_N TERM_N_R 0.30544f
C2396 HS_P_5 HS_P_2 0.03142f
C2397 HS_P FS_N_BLEED_5 0.08856f
C2398 HS_N BYPASS_ENABLE 0.01049f
C2399 TERM_N_R FS_P_BLEED_1 0.11444f
C2400 HS_N_8 HS_PBIAS 9.64282f
C2401 PAD_N TERM_VCM 0.001f
C2402 PULLUP_P PULLUP_N_CONTROL_S 0.00111f
C2403 HS_N_2 HS_N_13 0.12504p
C2404 TERM_GATE_P HS_N_3 0.11104f
C2405 DIV_LOW_N HS_N_6 0.06178f
C2406 a_43813_189064# a_42245_162628# 0.00994f
C2407 FS_HIGH_N TERM_P_R 0.00719f
C2408 PULLUP_P_BLEED_4 HS_N_1 0.03489f
C2409 a_41005_204945# a_41005_204385# 0.0346f
C2410 HS_P_5 HS_N_3 0.03489f
C2411 DIV_ENABLE PULLUP_N_BLEED_1 0.03564f
C2412 HS_P_11 HS_P_3 0.02877f
C2413 HS_N_6 FS_P_BLEED_1 0.06178f
C2414 HS_P TERM_OR_P_B 0.0917f
C2415 HS_P_11 VCM_LOW_OK 0.06673f
C2416 PULLUP_P_BLEED_6 HS_PBIAS 0.17406f
C2417 DIV_N VCM_LOW_OK 0
C2418 DIV_ENABLE HS_N_13 0.03089f
C2419 HS_N_4 HS_P_6 0.0599f
C2420 HS_P_4 HS_P_3 33.6448f
C2421 HS_P TERM_GATE_P 0.22621f
C2422 HS_P_4 VCM_LOW_OK 0.06673f
C2423 HS_P HS_P_5 5.05127f
C2424 HS_N_9 FS_LOW_P 0.21326f
C2425 PULLUP_P_OUT HS_N_2 0.02451f
C2426 BYPASS_ENABLE DIV_N 0.09436f
C2427 FS_P_BLEED_5 PULLDOWN_N_R 0.05931f
C2428 FS_LOW_N PULLUP_N_BLEED_1 0.07126f
C2429 TERM_P_R PULLDOWN_N 0.78117f
C2430 HS_N_9 HS_PBIAS 3.54149f
C2431 VDD FS_P_BLEED_0 0.25026f
C2432 FS_P_BLEED_0 HS_N_8 0.06178f
C2433 HS_N_12 HS_N_2 0.03554f
C2434 DIV_P PULLDOWN_N_R 0.01299f
C2435 HS_N FS_HIGH_P 0
C2436 FS_LOW_N HS_N_13 0.04574f
C2437 PULLUP_P PULLUP_P_BLEED_3 0.10387f
C2438 PULLUP_N_OUT FS_N_BLEED_2 0
C2439 FS_P_GATE FS_P_BLEED_2 0.19835f
C2440 PULLUP_N_OUT TERM_OR_N_S 0.14657f
C2441 TERM_OR_N_S TERM_GATE_N 0.01207f
C2442 PULLUP_P_GATE FS_HIGH_P 0.02645f
C2443 FS_HIGH_N VDD 0.05682f
C2444 PULLUP_N_BLEED_2 FS_HIGH_P 0.01347f
C2445 HS_P_13 HS_N_4 0.02957f
C2446 TERM_P_R HS_P_10 0.14229f
C2447 HS_N_4 PAD_P 0.06517f
C2448 HS_N_12 DIV_ENABLE 0.03143f
C2449 TERM_GATE_N_BLEED_1 HS_N_0 0.03489f
C2450 HS_N_6 FS_P_CONTROL_S 0.03226f
C2451 FS_LOW_P HS_P_9 0.05657f
C2452 DIV_N FS_HIGH_P 8.52636f
C2453 PULLUP_P_CONTROL_S TERM_ENABLE 0.05711f
C2454 TERM_P_R HS_P_1 0.10249f
C2455 PULLUP_N_OUT TERM_GATE_N 0.27495f
C2456 a_41005_203545# a_41005_204385# 0
C2457 HS_P_11 TERM_GATE_P_BLEED_0 0.03689f
C2458 HS_N_9 FS_P_BLEED_0 0.06178f
C2459 VDD PULLDOWN_N 0.45423f
C2460 HS_P_9 HS_PBIAS 3.39603f
C2461 PULLUP_P_BLEED_4 HS_N_2 0.03489f
C2462 PULLUP_N_BLEED_6 PULLUP_N 0.05624f
C2463 FS_LOW_N HS_N_12 0.04599f
C2464 HS_P_10 TERM_OR_P_NS 0.04329f
C2465 HS_P_4 TERM_GATE_P_BLEED_0 0.02451f
C2466 PULLUP_P_CONTROL_S HS_N_5 0.03489f
C2467 FS_N_OUT FS_N_GATE 0.1495p
C2468 FS_N_BLEED_5 FS_LOW_P 0.06639f
C2469 PULLUP_P_BLEED_4 DIV_ENABLE 0.01375f
C2470 VDD HS_P_10 6.63169f
C2471 FS_LOW_P TERM_OR_P_B 1.1369f
C2472 FS_N_BLEED_5 HS_PBIAS 0.08856f
C2473 HS_P_1 TERM_OR_P_NS 0.04312f
C2474 PULLUP_P PULLUP_P_WELL 0.41138f
C2475 HS_N_8 HS_P_10 0.0286f
C2476 TERM_P_R HS_P_6 0.08356f
C2477 DIV_LOW_N HS_N_3 0.06178f
C2478 PULLDOWN_N_R PULLUP_N_BLEED_1 0.04848f
C2479 FS_LOW_P TERM_GATE_P 0.15357f
C2480 FS_P_BLEED_1 HS_N_3 0.06178f
C2481 HS_N_6 FS_P_BLEED_6 0.06178f
C2482 VDD HS_P_1 5.54122f
C2483 PULLUP_N_OUT TERM_GATE_P_BLEED_1 0.05318f
C2484 FS_N_OUT VCM_LOW_OK 0.06167f
C2485 FS_LOW_P HS_P_5 0.17341f
C2486 HS_N_8 HS_P_1 0.02866f
C2487 FS_P_GATE HS_N_4 1.011f
C2488 PULLUP_P_BLEED_4 FS_LOW_N 0.02199f
C2489 HS_PBIAS TERM_GATE_P 0.02241f
C2490 HS_N_13 PULLDOWN_N_R 0.06832f
C2491 DIV_LOW_N HS_P 0.06178f
C2492 HS_P FS_P_BLEED_1 0.06178f
C2493 HS_P_5 HS_PBIAS 3.80328f
C2494 ESD_RAIL PAD_P 24.1165f
C2495 PULLUP_P_CONTROL_S PULLDOWN_P_R 0.05462f
C2496 TERM_ENABLE TERM_OR_N_S 7.06942f
C2497 HS_N TERM_OR_N_B 0.08496f
C2498 PULLUP_P_BLEED_5 HS_N_7 0.0525f
C2499 HS_P_13 TERM_P_R 0.08554f
C2500 HS_P_6 TERM_OR_P_NS 0.02846f
C2501 HS_N_9 HS_P_10 0.03109f
C2502 TERM_VCM TERM_GATE_P_BLEED_2 0.02194f
C2503 TERM_P_R PAD_P 0.15545f
C2504 PULLUP_P_OUT PULLDOWN_N_R 0.04901f
C2505 DIV_P TERM_VCM 0.13218f
C2506 VDD HS_P_6 6.8233f
C2507 PULLUP_P_WELL FS_P_BLEED_1 0
C2508 FS_N_WELL FS_N_BLEED_0 0.38234f
C2509 HS_N_5 TERM_OR_N_S 0.06593f
C2510 HS_N_4 HS_P_0 0.03432f
C2511 PULLUP_N_OUT TERM_ENABLE 0.19243f
C2512 m2_42279_196800# a_41005_204385# 0
C2513 PULLUP_N_OUT PULLUP_N_BLEED_3 0
C2514 FS_P_BLEED_3 FS_HIGH_P 0.03577f
C2515 TERM_ENABLE TERM_GATE_N 10.7923f
C2516 HS_N_9 HS_P_1 0.0312f
C2517 HS_N_8 HS_P_6 0.04808f
C2518 HS_N_12 PULLDOWN_N_R 0.06159f
C2519 HS_N_11 HS_N_0 0.03964f
C2520 FS_P_CONTROL_S HS_N_3 0.03226f
C2521 TERM_GATE_N_BLEED_1 HS_N_10 0.03489f
C2522 FS_N_WELL DIV_ENABLE 0.24754f
C2523 FS_P_BLEED_4 FS_P_BLEED_6 0.12036f
C2524 PULLUP_N_OUT HS_N_5 0.0184f
C2525 FS_N_OUT FS_HIGH_P 0.0917f
C2526 HS_P_13 TERM_OR_P_NS 0.02895f
C2527 HS_N_5 TERM_GATE_N 0.05061f
C2528 a_44789_189064# a_42245_162628# 10.1844f
C2529 HS_N_7 FS_P_BLEED_2 0.03472f
C2530 TERM_N_R PULLUP_P_BLEED_2 0.05729f
C2531 HS_P FS_P_CONTROL_S 0.03246f
C2532 VDD HS_P_13 6.64318f
C2533 HS_P_9 HS_P_10 0.00887f
C2534 RX_N VSS 40.3558f
C2535 RX_P VSS 39.629f
C2536 BYPASS_ENABLE VSS 60.4691f
C2537 HS_N VSS 56.6296f
C2538 HS_P VSS 40.6952f
C2539 FS_LOW_P VSS 37.9174f
C2540 PAD_P VSS 0.40498p
C2541 PAD_N VSS 0.40071p
C2542 FS_HIGH_P VSS 6.70592f
C2543 PULLUP_P VSS 20.3883f
C2544 PULLDOWN_P VSS 13.3462f
C2545 FS_LOW_N VSS 9.08884f
C2546 TERM_ENABLE VSS 50.7567f
C2547 DIV_ENABLE VSS 22.474f
C2548 TERM_VCM VSS 0.11532p
C2549 HS_PBIAS VSS 49.7764f
C2550 FS_HIGH_N VSS 3.65235f
C2551 PULLUP_N VSS 3.16537f
C2552 PULLDOWN_N VSS 5.09355f
C2553 DIFF_ENABLE VSS 14.2384f
C2554 ESD_RAIL VSS 1674.155664f
C2555 VDD VSS 0.73309p
C2556 m2_42279_196800# VSS 7.46506f $ **FLOATING
C2557 TERM_OR_P_S VSS 3.53275f
C2558 TERM_OR_P_NS VSS 10.0639f
C2559 TERM_GATE_P_BLEED_2 VSS 3.28565f
C2560 TERM_GATE_P_BLEED_1 VSS 5.10072f
C2561 TERM_GATE_P_BLEED_0 VSS 7.68181f
C2562 TERM_OR_P_B VSS 21.153f
C2563 TERM_GATE_P VSS 27.0289f
C2564 HS_P_4 VSS 7.08828f
C2565 HS_P_3 VSS 7.10742f
C2566 HS_P_2 VSS 6.92881f
C2567 HS_P_1 VSS 5.64833f
C2568 HS_P_0 VSS 7.04643f
C2569 DIV_LOW_P VSS 7.23693f
C2570 DIV_P VSS 14.1199f
C2571 HS_P_11 VSS 8.66739f
C2572 HS_P_10 VSS 6.56271f
C2573 HS_P_9 VSS 7.07185f
C2574 HS_P_8 VSS 5.6877f
C2575 HS_P_7 VSS 4.83643f
C2576 HS_P_6 VSS 5.96197f
C2577 HS_P_5 VSS 7.82827f
C2578 HS_P_13 VSS 6.1434f
C2579 HS_P_12 VSS 7.62117f
C2580 a_42245_162628# VSS 0.24797p
C2581 a_44789_189064# VSS 12.0947f
C2582 a_43813_189064# VSS 5.60447f
C2583 FS_P_BLEED_1 VSS 5.43583f
C2584 FS_P_BLEED_0 VSS 4.65475f
C2585 FS_P_CONTROL_S VSS 4.50476f
C2586 FS_P_OUT VSS 33.2921f
C2587 FS_P_GATE VSS 49.168f
C2588 FS_P_BLEED_6 VSS 4.11494f
C2589 FS_P_BLEED_5 VSS 3.49709f
C2590 FS_P_BLEED_4 VSS 3.14909f
C2591 FS_P_BLEED_3 VSS 3.74932f
C2592 FS_P_BLEED_2 VSS 8.09567f
C2593 PULLUP_P_OUT VSS 19.8908f
C2594 a_41005_203545# VSS 0.10822p
C2595 a_53878_203545# VSS 0.07835f
C2596 a_41005_203825# VSS 0.07377f
C2597 a_53878_204105# VSS 0.07394f
C2598 a_41005_204385# VSS 0.07377f
C2599 a_53878_204665# VSS 0.07394f
C2600 a_41005_204945# VSS 0.07377f
C2601 a_53878_205225# VSS 0.07394f
C2602 a_41005_205505# VSS 0.07377f
C2603 a_53878_205785# VSS 0.07394f
C2604 a_41005_206065# VSS 0.07377f
C2605 PULLUP_P_BLEED_3 VSS 4.19596f
C2606 PULLUP_P_BLEED_2 VSS 3.20038f
C2607 PULLUP_P_BLEED_1 VSS 3.21015f
C2608 PULLUP_P_BLEED_0 VSS 5.16157f
C2609 PULLUP_P_CONTROL_S VSS 6.8319f
C2610 a_53878_206345# VSS 0.07838f
C2611 TERM_OR_N_NS VSS 4.57584f
C2612 PULLDOWN_P_R VSS 21.0115f
C2613 PULLUP_P_GATE VSS 20.3625f
C2614 PULLUP_P_BLEED_6 VSS 8.95891f
C2615 PULLUP_P_BLEED_5 VSS 11.915f
C2616 PULLUP_P_BLEED_4 VSS 8.3128f
C2617 TERM_GATE_N_BLEED_0 VSS 3.5755f
C2618 VCM_LOW_OK VSS 18.5309f
C2619 TERM_OR_N_B VSS 10.5692f
C2620 TERM_OR_N_S VSS 5.67982f
C2621 TERM_GATE_N_BLEED_2 VSS 19.0723f
C2622 TERM_GATE_N_BLEED_1 VSS 8.32567f
C2623 HS_N_1 VSS 10.8501f
C2624 HS_N_0 VSS 11.5562f
C2625 DIV_LOW_N VSS 7.76439f
C2626 DIV_N VSS 18.3189f
C2627 TERM_GATE_N VSS 16.1057f
C2628 HS_N_8 VSS 9.4609f
C2629 HS_N_7 VSS 8.02897f
C2630 HS_N_6 VSS 8.95527f
C2631 HS_N_5 VSS 8.31305f
C2632 HS_N_4 VSS 7.38867f
C2633 HS_N_3 VSS 7.80958f
C2634 HS_N_2 VSS 9.75539f
C2635 HS_N_13 VSS 8.71443f
C2636 HS_N_12 VSS 9.8184f
C2637 HS_N_11 VSS 9.16147f
C2638 HS_N_10 VSS 8.85941f
C2639 HS_N_9 VSS 9.6175f
C2640 FS_N_CONTROL_S VSS 5.47781f
C2641 FS_N_OUT VSS 66.8924f
C2642 FS_N_BLEED_5 VSS 5.98424f
C2643 FS_N_BLEED_4 VSS 4.95494f
C2644 FS_N_BLEED_3 VSS 4.3843f
C2645 FS_N_BLEED_2 VSS 3.88073f
C2646 FS_N_BLEED_1 VSS 3.51561f
C2647 FS_N_BLEED_0 VSS 3.27574f
C2648 FS_N_GATE VSS 52.4489f
C2649 FS_N_BLEED_6 VSS 8.07787f
C2650 PULLUP_N_BLEED_0 VSS 4.40019f
C2651 PULLUP_N_CONTROL_S VSS 4.58281f
C2652 PULLUP_N_OUT VSS 44.40639f
C2653 PULLDOWN_N_R VSS 36.3783f
C2654 PULLUP_N_GATE VSS 12.7893f
C2655 PULLUP_N_BLEED_6 VSS 3.40901f
C2656 PULLUP_N_BLEED_5 VSS 3.00905f
C2657 PULLUP_N_BLEED_4 VSS 4.15562f
C2658 PULLUP_N_BLEED_3 VSS 6.97402f
C2659 PULLUP_N_BLEED_2 VSS 9.92042f
C2660 PULLUP_N_BLEED_1 VSS 8.17871f
C2661 TERM_P_R VSS 95.55199f
C2662 TERM_N_R VSS 0.11939p
C2663 FS_P_WELL VSS 0.42754p
C2664 PULLUP_P_WELL VSS 96.6713f
C2665 FS_N_WELL VSS 0.4392p
C2666 PULLUP_N_WELL VSS 95.1067f
DWELL_ARRAY VSS ESD_RAIL diode_nw2ps_06v0 area=569.4528p pj=470.72u
.ends

.lib /home/ubuntu/svalbard/scratch/transceiver-pad-pdk/ngspice/sm141064.ngspice diode_typical
.lib /home/ubuntu/svalbard/scratch/transceiver-pad-pdk/ngspice/sm141064.ngspice mimcap_typical
