* NGSPICE file created from bleed.ext - technology: gf180mcuD

.subckt bleed RAIL VSS BODY
X0 VSS RAIL BODY ppolyf_u_1k_6p0 r_width=1u r_length=0.31954m
C0 VSS RAIL 0.00397f
C1 VSS BODY 0.3039f
C2 RAIL BODY 0.3039f
.ends
