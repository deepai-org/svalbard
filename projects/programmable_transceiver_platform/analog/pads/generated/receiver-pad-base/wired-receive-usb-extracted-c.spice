* Independent exporter of physical Magic .ext; no schematic substitutions.
* Extracted capacitance included; distributed wire resistance remains absent.
.subckt pad_wired_receive_usb_flat_physical PAD_P PAD_N VDD VSS TERM_VCM TERM_ENABLE DIFF_ENABLE DIV_ENABLE BYPASS_ENABLE RX_P RX_N HS_PBIAS HS_P HS_N FS_HIGH_P FS_HIGH_N FS_LOW_P FS_LOW_N PULLUP_P PULLUP_N PULLDOWN_P PULLDOWN_N
X0 PAD_N VSS VSS VSS nfet_06v0_dss w=16u l=0.6u ad=60.48p as=4.48p pd=39.56u ps=32.56u d_sab=3.78u s_sab=0.28u
X1 PAD_N VSS VSS VSS nfet_06v0_dss w=16u l=0.6u ad=60.48p as=4.48p pd=39.56u ps=32.56u d_sab=3.78u s_sab=0.28u
X2 PAD_P VSS VSS VSS nfet_06v0_dss w=16u l=0.6u ad=60.48p as=4.48p pd=39.56u ps=32.56u d_sab=3.78u s_sab=0.28u
X3 PAD_P VSS VSS VSS nfet_06v0_dss w=16u l=0.6u ad=60.48p as=4.48p pd=39.56u ps=32.56u d_sab=3.78u s_sab=0.28u
X4 PAD_N BYPASS_ENABLE RX_N VSS nfet_06v0 w=20u l=0.7u ad=8.8p as=8.8p pd=40.88u ps=40.88u
X5 PAD_P BYPASS_ENABLE RX_P VSS nfet_06v0 w=20u l=0.7u ad=8.8p as=8.8p pd=40.88u ps=40.88u
X6 PAD_N BYPASS_ENABLE RX_N VSS nfet_06v0 w=20u l=0.7u ad=8.8p as=8.8p pd=40.88u ps=40.88u
X7 PAD_P BYPASS_ENABLE RX_P VSS nfet_06v0 w=20u l=0.7u ad=8.8p as=8.8p pd=40.88u ps=40.88u
X8 PAD_N BYPASS_ENABLE RX_N VSS nfet_06v0 w=20u l=0.7u ad=8.8p as=8.8p pd=40.88u ps=40.88u
X9 PAD_P BYPASS_ENABLE RX_P VSS nfet_06v0 w=20u l=0.7u ad=8.8p as=8.8p pd=40.88u ps=40.88u
X10 PAD_N BYPASS_ENABLE RX_N VSS nfet_06v0 w=20u l=0.7u ad=8.8p as=8.8p pd=40.88u ps=40.88u
X11 PAD_P FS_P_OUT VSS ppolyf_s r_width=1u r_length=2.16u
X12 PAD_N FS_N_OUT VSS ppolyf_s r_width=1u r_length=2.16u
X13 DIV_P PAD_P VSS ppolyf_u_1k r_width=1u r_length=2u
X14 DIV_N PAD_N VSS ppolyf_u_1k r_width=1u r_length=2u
X15 DIV_P DIV_ENABLE RX_P VSS nfet_06v0 w=20u l=0.7u ad=8.8p as=8.8p pd=40.88u ps=40.88u
X16 DIV_N DIV_ENABLE RX_N VSS nfet_06v0 w=20u l=0.7u ad=8.8p as=8.8p pd=40.88u ps=40.88u
X17 PAD_P BYPASS_ENABLE RX_P VSS nfet_06v0 w=20u l=0.7u ad=8.8p as=8.8p pd=40.88u ps=40.88u
X18 HS_N_12 HS_N PAD_N VSS nfet_06v0 w=20u l=0.7u ad=8.8p as=8.8p pd=40.88u ps=40.88u
X19 HS_P_11 HS_P PAD_P VSS nfet_06v0 w=20u l=0.7u ad=8.8p as=8.8p pd=40.88u ps=40.88u
X20 HS_N_11 HS_N PAD_N VSS nfet_06v0 w=20u l=0.7u ad=8.8p as=8.8p pd=40.88u ps=40.88u
X21 HS_P_10 HS_P PAD_P VSS nfet_06v0 w=20u l=0.7u ad=8.8p as=8.8p pd=40.88u ps=40.88u
X22 HS_N_10 HS_N PAD_N VSS nfet_06v0 w=20u l=0.7u ad=8.8p as=8.8p pd=40.88u ps=40.88u
X23 HS_P_0 HS_P PAD_P VSS nfet_06v0 w=20u l=0.7u ad=8.8p as=8.8p pd=40.88u ps=40.88u
X24 HS_N_0 HS_N PAD_N VSS nfet_06v0 w=20u l=0.7u ad=8.8p as=8.8p pd=40.88u ps=40.88u
X25 HS_P_2 HS_P PAD_P VSS nfet_06v0 w=20u l=0.7u ad=8.8p as=8.8p pd=40.88u ps=40.88u
X26 HS_N_2 HS_N PAD_N VSS nfet_06v0 w=20u l=0.7u ad=8.8p as=8.8p pd=40.88u ps=40.88u
X27 HS_P_1 HS_P PAD_P VSS nfet_06v0 w=20u l=0.7u ad=8.8p as=8.8p pd=40.88u ps=40.88u
X28 HS_N_1 HS_N PAD_N VSS nfet_06v0 w=20u l=0.7u ad=8.8p as=8.8p pd=40.88u ps=40.88u
X29 HS_P_13 HS_P PAD_P VSS nfet_06v0 w=20u l=0.7u ad=8.8p as=8.8p pd=40.88u ps=40.88u
X30 HS_N_13 HS_N PAD_N VSS nfet_06v0 w=20u l=0.7u ad=8.8p as=8.8p pd=40.88u ps=40.88u
X31 HS_P_12 HS_P PAD_P VSS nfet_06v0 w=20u l=0.7u ad=8.8p as=8.8p pd=40.88u ps=40.88u
X32 HS_N_6 HS_N PAD_N VSS nfet_06v0 w=20u l=0.7u ad=8.8p as=8.8p pd=40.88u ps=40.88u
X33 HS_P_5 HS_P PAD_P VSS nfet_06v0 w=20u l=0.7u ad=8.8p as=8.8p pd=40.88u ps=40.88u
X34 HS_N_5 HS_N PAD_N VSS nfet_06v0 w=20u l=0.7u ad=8.8p as=8.8p pd=40.88u ps=40.88u
X35 HS_P_4 HS_P PAD_P VSS nfet_06v0 w=20u l=0.7u ad=8.8p as=8.8p pd=40.88u ps=40.88u
X36 HS_N_4 HS_N PAD_N VSS nfet_06v0 w=20u l=0.7u ad=8.8p as=8.8p pd=40.88u ps=40.88u
X37 HS_P_3 HS_P PAD_P VSS nfet_06v0 w=20u l=0.7u ad=8.8p as=8.8p pd=40.88u ps=40.88u
X38 HS_N_3 HS_N PAD_N VSS nfet_06v0 w=20u l=0.7u ad=8.8p as=8.8p pd=40.88u ps=40.88u
X39 HS_P_9 HS_P PAD_P VSS nfet_06v0 w=20u l=0.7u ad=8.8p as=8.8p pd=40.88u ps=40.88u
X40 HS_N_9 HS_N PAD_N VSS nfet_06v0 w=20u l=0.7u ad=8.8p as=8.8p pd=40.88u ps=40.88u
X41 HS_P_8 HS_P PAD_P VSS nfet_06v0 w=20u l=0.7u ad=8.8p as=8.8p pd=40.88u ps=40.88u
X42 HS_N_8 HS_N PAD_N VSS nfet_06v0 w=20u l=0.7u ad=8.8p as=8.8p pd=40.88u ps=40.88u
X43 HS_P_7 HS_P PAD_P VSS nfet_06v0 w=20u l=0.7u ad=8.8p as=8.8p pd=40.88u ps=40.88u
X44 HS_N_7 HS_N PAD_N VSS nfet_06v0 w=20u l=0.7u ad=8.8p as=8.8p pd=40.88u ps=40.88u
X45 HS_P_6 HS_P PAD_P VSS nfet_06v0 w=20u l=0.7u ad=8.8p as=8.8p pd=40.88u ps=40.88u
X46 VCM_LOW_OK TERM_VCM VSS VSS nfet_03v3 w=8u l=0.28u ad=3.52p as=3.52p pd=16.88u ps=16.88u
X47 TERM_P_R PAD_P VSS ppolyf_s r_width=1u r_length=3.29u
X48 TERM_N_R PAD_N VSS ppolyf_s r_width=1u r_length=3.29u
X49 PAD_P PULLUP_P_OUT VSS ppolyf_u_1k r_width=1u r_length=1.18u
X50 PAD_N PULLUP_N_OUT VSS ppolyf_u_1k r_width=1u r_length=1.18u
X51 PULLDOWN_P_R PAD_P VSS ppolyf_u_1k r_width=1u r_length=14.2u
X52 PULLDOWN_N_R PAD_N VSS ppolyf_u_1k r_width=1u r_length=14.2u
X53 TERM_OR_P_B VCM_LOW_OK TERM_OR_P_S VDD pfet_03v3 w=4u l=0.28u ad=1.76p as=1.76p pd=8.88u ps=8.88u
X54 TERM_OR_P_B FS_LOW_P TERM_OR_P_S VDD pfet_03v3 w=4u l=0.28u ad=1.76p as=1.76p pd=8.88u ps=8.88u
X55 TERM_OR_P_S TERM_ENABLE VDD VDD pfet_03v3 w=4u l=0.28u ad=1.76p as=1.76p pd=8.88u ps=8.88u
X56 TERM_OR_P_NS VCM_LOW_OK VSS VSS nfet_03v3 w=4u l=0.28u ad=1.76p as=1.76p pd=8.88u ps=8.88u
X57 TERM_OR_P_B FS_LOW_P TERM_OR_P_NS VSS nfet_03v3 w=2u l=0.28u ad=0.88p as=0.88p pd=4.88u ps=4.88u
X58 TERM_OR_P_B TERM_ENABLE VSS VSS nfet_03v3 w=2u l=0.28u ad=0.88p as=0.88p pd=4.88u ps=4.88u
X59 VCM_LOW_OK TERM_VCM VDD VDD pfet_03v3 w=2u l=0.28u ad=0.88p as=0.88p pd=4.88u ps=4.88u
X60 TERM_P_R TERM_GATE_P TERM_VCM VSS nfet_03v3 w=20u l=0.28u ad=8.8p as=8.8p pd=40.88u ps=40.88u
X61 VSS TERM_GATE_P_BLEED_2 VSS ppolyf_u_1k r_width=1u r_length=12.5u
X62 TERM_GATE_P_BLEED_2 TERM_GATE_P_BLEED_1 VSS ppolyf_u_1k r_width=1u r_length=12.5u
X63 TERM_GATE_P_BLEED_1 TERM_GATE_P_BLEED_0 VSS ppolyf_u_1k r_width=1u r_length=12.5u
X64 TERM_GATE_P_BLEED_0 TERM_GATE_P VSS ppolyf_u_1k r_width=1u r_length=12.5u
X65 TERM_GATE_P TERM_OR_P_B VDD VDD pfet_03v3 w=8u l=0.28u ad=3.52p as=3.52p pd=16.88u ps=16.88u
X66 TERM_GATE_P TERM_OR_P_B VSS VSS nfet_03v3 w=4u l=0.28u ad=1.76p as=1.76p pd=8.88u ps=8.88u
X67 TERM_P_R TERM_GATE_P TERM_VCM VSS nfet_03v3 w=20u l=0.28u ad=8.8p as=8.8p pd=40.88u ps=40.88u
X68 TERM_P_R TERM_GATE_P TERM_VCM VSS nfet_03v3 w=20u l=0.28u ad=8.8p as=8.8p pd=40.88u ps=40.88u
X69 TERM_P_R TERM_GATE_P TERM_VCM VSS nfet_03v3 w=20u l=0.28u ad=8.8p as=8.8p pd=40.88u ps=40.88u
X70 TERM_P_R TERM_GATE_P TERM_VCM VSS nfet_03v3 w=20u l=0.28u ad=8.8p as=8.8p pd=40.88u ps=40.88u
X71 TERM_P_R TERM_GATE_P TERM_VCM VSS nfet_03v3 w=20u l=0.28u ad=8.8p as=8.8p pd=40.88u ps=40.88u
X72 TERM_P_R TERM_GATE_P TERM_VCM VSS nfet_03v3 w=20u l=0.28u ad=8.8p as=8.8p pd=40.88u ps=40.88u
X73 TERM_P_R TERM_GATE_P TERM_VCM VSS nfet_03v3 w=20u l=0.28u ad=8.8p as=8.8p pd=40.88u ps=40.88u
X74 HS_P_4 HS_PBIAS VDD VDD pfet_03v3 w=20u l=1u ad=8.8p as=8.8p pd=40.88u ps=40.88u
X75 HS_P_3 HS_PBIAS VDD VDD pfet_03v3 w=20u l=1u ad=8.8p as=8.8p pd=40.88u ps=40.88u
X76 HS_P_2 HS_PBIAS VDD VDD pfet_03v3 w=20u l=1u ad=8.8p as=8.8p pd=40.88u ps=40.88u
X77 HS_P_1 HS_PBIAS VDD VDD pfet_03v3 w=20u l=1u ad=8.8p as=8.8p pd=40.88u ps=40.88u
X78 HS_P_0 HS_PBIAS VDD VDD pfet_03v3 w=20u l=1u ad=8.8p as=8.8p pd=40.88u ps=40.88u
X79 DIV_LOW_P DIV_ENABLE VSS VSS nfet_03v3 w=20u l=0.28u ad=8.8p as=8.8p pd=40.88u ps=40.88u
X80 DIV_LOW_P DIV_P VSS ppolyf_u_1k r_width=1u r_length=2u
X81 HS_P_11 HS_PBIAS VDD VDD pfet_03v3 w=20u l=1u ad=8.8p as=8.8p pd=40.88u ps=40.88u
X82 HS_P_10 HS_PBIAS VDD VDD pfet_03v3 w=20u l=1u ad=8.8p as=8.8p pd=40.88u ps=40.88u
X83 HS_P_9 HS_PBIAS VDD VDD pfet_03v3 w=20u l=1u ad=8.8p as=8.8p pd=40.88u ps=40.88u
X84 HS_P_8 HS_PBIAS VDD VDD pfet_03v3 w=20u l=1u ad=8.8p as=8.8p pd=40.88u ps=40.88u
X85 HS_P_7 HS_PBIAS VDD VDD pfet_03v3 w=20u l=1u ad=8.8p as=8.8p pd=40.88u ps=40.88u
X86 HS_P_6 HS_PBIAS VDD VDD pfet_03v3 w=20u l=1u ad=8.8p as=8.8p pd=40.88u ps=40.88u
X87 HS_P_5 HS_PBIAS VDD VDD pfet_03v3 w=20u l=1u ad=8.8p as=8.8p pd=40.88u ps=40.88u
X88 VDD FS_P_GATE FS_P_WELL FS_P_WELL pfet_03v3 w=20u l=0.28u ad=8.8p as=8.8p pd=40.88u ps=40.88u
X89 FS_P_OUT FS_P_GATE FS_P_WELL FS_P_WELL pfet_03v3 w=20u l=0.28u ad=8.8p as=8.8p pd=40.88u ps=40.88u
X90 VDD FS_P_GATE FS_P_WELL FS_P_WELL pfet_03v3 w=20u l=0.28u ad=8.8p as=8.8p pd=40.88u ps=40.88u
X91 FS_P_OUT FS_P_GATE FS_P_WELL FS_P_WELL pfet_03v3 w=20u l=0.28u ad=8.8p as=8.8p pd=40.88u ps=40.88u
X92 VDD FS_P_GATE FS_P_WELL FS_P_WELL pfet_03v3 w=20u l=0.28u ad=8.8p as=8.8p pd=40.88u ps=40.88u
X93 HS_P_13 HS_PBIAS VDD VDD pfet_03v3 w=20u l=1u ad=8.8p as=8.8p pd=40.88u ps=40.88u
X94 HS_P_12 HS_PBIAS VDD VDD pfet_03v3 w=20u l=1u ad=8.8p as=8.8p pd=40.88u ps=40.88u
X95 FS_P_OUT FS_P_GATE FS_P_WELL FS_P_WELL pfet_03v3 w=20u l=0.28u ad=8.8p as=8.8p pd=40.88u ps=40.88u
X96 VDD FS_P_GATE FS_P_WELL FS_P_WELL pfet_03v3 w=20u l=0.28u ad=8.8p as=8.8p pd=40.88u ps=40.88u
X97 FS_P_OUT FS_P_GATE FS_P_WELL FS_P_WELL pfet_03v3 w=20u l=0.28u ad=8.8p as=8.8p pd=40.88u ps=40.88u
X98 VDD FS_P_GATE FS_P_WELL FS_P_WELL pfet_03v3 w=20u l=0.28u ad=8.8p as=8.8p pd=40.88u ps=40.88u
X99 FS_P_OUT FS_P_GATE FS_P_WELL FS_P_WELL pfet_03v3 w=20u l=0.28u ad=8.8p as=8.8p pd=40.88u ps=40.88u
X100 VDD FS_P_GATE FS_P_WELL FS_P_WELL pfet_03v3 w=20u l=0.28u ad=8.8p as=8.8p pd=40.88u ps=40.88u
X101 FS_P_OUT FS_P_GATE FS_P_WELL FS_P_WELL pfet_03v3 w=20u l=0.28u ad=8.8p as=8.8p pd=40.88u ps=40.88u
X102 VDD FS_P_GATE FS_P_WELL FS_P_WELL pfet_03v3 w=20u l=0.28u ad=8.8p as=8.8p pd=40.88u ps=40.88u
X103 FS_P_OUT FS_P_GATE FS_P_WELL FS_P_WELL pfet_03v3 w=20u l=0.28u ad=8.8p as=8.8p pd=40.88u ps=40.88u
X104 VDD FS_P_GATE FS_P_WELL FS_P_WELL pfet_03v3 w=20u l=0.28u ad=8.8p as=8.8p pd=40.88u ps=40.88u
X105 FS_P_OUT FS_P_GATE FS_P_WELL FS_P_WELL pfet_03v3 w=20u l=0.28u ad=8.8p as=8.8p pd=40.88u ps=40.88u
X106 VDD FS_P_GATE FS_P_WELL FS_P_WELL pfet_03v3 w=20u l=0.28u ad=8.8p as=8.8p pd=40.88u ps=40.88u
X107 FS_P_OUT FS_P_GATE FS_P_WELL FS_P_WELL pfet_03v3 w=20u l=0.28u ad=8.8p as=8.8p pd=40.88u ps=40.88u
X108 VDD FS_P_GATE FS_P_WELL FS_P_WELL pfet_03v3 w=20u l=0.28u ad=8.8p as=8.8p pd=40.88u ps=40.88u
X109 FS_P_OUT FS_P_GATE FS_P_WELL FS_P_WELL pfet_03v3 w=20u l=0.28u ad=8.8p as=8.8p pd=40.88u ps=40.88u
X110 VDD FS_P_GATE FS_P_WELL FS_P_WELL pfet_03v3 w=20u l=0.28u ad=8.8p as=8.8p pd=40.88u ps=40.88u
X111 FS_P_OUT FS_P_GATE FS_P_WELL FS_P_WELL pfet_03v3 w=20u l=0.28u ad=8.8p as=8.8p pd=40.88u ps=40.88u
X112 VDD FS_P_GATE FS_P_WELL FS_P_WELL pfet_03v3 w=20u l=0.28u ad=8.8p as=8.8p pd=40.88u ps=40.88u
X113 FS_P_OUT FS_P_GATE FS_P_WELL FS_P_WELL pfet_03v3 w=20u l=0.28u ad=8.8p as=8.8p pd=40.88u ps=40.88u
X114 VDD FS_P_GATE FS_P_WELL FS_P_WELL pfet_03v3 w=20u l=0.28u ad=8.8p as=8.8p pd=40.88u ps=40.88u
X115 FS_P_OUT FS_P_GATE FS_P_WELL FS_P_WELL pfet_03v3 w=20u l=0.28u ad=8.8p as=8.8p pd=40.88u ps=40.88u
X116 VDD FS_P_GATE FS_P_WELL FS_P_WELL pfet_03v3 w=20u l=0.28u ad=8.8p as=8.8p pd=40.88u ps=40.88u
X117 FS_P_OUT FS_P_GATE FS_P_WELL FS_P_WELL pfet_03v3 w=20u l=0.28u ad=8.8p as=8.8p pd=40.88u ps=40.88u
X118 VDD FS_P_GATE FS_P_WELL FS_P_WELL pfet_03v3 w=20u l=0.28u ad=8.8p as=8.8p pd=40.88u ps=40.88u
X119 FS_P_OUT FS_P_GATE FS_P_WELL FS_P_WELL pfet_03v3 w=20u l=0.28u ad=8.8p as=8.8p pd=40.88u ps=40.88u
X120 VDD FS_P_GATE FS_P_WELL FS_P_WELL pfet_03v3 w=20u l=0.28u ad=8.8p as=8.8p pd=40.88u ps=40.88u
X121 FS_P_OUT FS_P_GATE FS_P_WELL FS_P_WELL pfet_03v3 w=20u l=0.28u ad=8.8p as=8.8p pd=40.88u ps=40.88u
X122 VDD FS_P_GATE FS_P_WELL FS_P_WELL pfet_03v3 w=20u l=0.28u ad=8.8p as=8.8p pd=40.88u ps=40.88u
X123 FS_P_OUT FS_P_GATE FS_P_WELL FS_P_WELL pfet_03v3 w=20u l=0.28u ad=8.8p as=8.8p pd=40.88u ps=40.88u
X124 VDD FS_P_GATE FS_P_WELL FS_P_WELL pfet_03v3 w=20u l=0.28u ad=8.8p as=8.8p pd=40.88u ps=40.88u
X125 FS_P_OUT FS_P_GATE FS_P_WELL FS_P_WELL pfet_03v3 w=20u l=0.28u ad=8.8p as=8.8p pd=40.88u ps=40.88u
X126 VDD FS_P_GATE FS_P_WELL FS_P_WELL pfet_03v3 w=20u l=0.28u ad=8.8p as=8.8p pd=40.88u ps=40.88u
X127 FS_P_OUT FS_P_GATE FS_P_WELL FS_P_WELL pfet_03v3 w=20u l=0.28u ad=8.8p as=8.8p pd=40.88u ps=40.88u
X128 VDD FS_P_GATE FS_P_WELL FS_P_WELL pfet_03v3 w=20u l=0.28u ad=8.8p as=8.8p pd=40.88u ps=40.88u
X129 FS_P_OUT FS_P_GATE FS_P_WELL FS_P_WELL pfet_03v3 w=20u l=0.28u ad=8.8p as=8.8p pd=40.88u ps=40.88u
X130 VDD FS_P_GATE FS_P_WELL FS_P_WELL pfet_03v3 w=20u l=0.28u ad=8.8p as=8.8p pd=40.88u ps=40.88u
X131 FS_P_OUT FS_P_GATE FS_P_WELL FS_P_WELL pfet_03v3 w=20u l=0.28u ad=8.8p as=8.8p pd=40.88u ps=40.88u
X132 VDD FS_P_GATE FS_P_WELL FS_P_WELL pfet_03v3 w=20u l=0.28u ad=8.8p as=8.8p pd=40.88u ps=40.88u
X133 FS_P_OUT FS_P_GATE FS_P_WELL FS_P_WELL pfet_03v3 w=20u l=0.28u ad=8.8p as=8.8p pd=40.88u ps=40.88u
X134 VDD FS_P_GATE FS_P_WELL FS_P_WELL pfet_03v3 w=20u l=0.28u ad=8.8p as=8.8p pd=40.88u ps=40.88u
X135 FS_P_OUT FS_P_GATE FS_P_WELL FS_P_WELL pfet_03v3 w=20u l=0.28u ad=8.8p as=8.8p pd=40.88u ps=40.88u
X136 VDD FS_P_GATE FS_P_WELL FS_P_WELL pfet_03v3 w=20u l=0.28u ad=8.8p as=8.8p pd=40.88u ps=40.88u
X137 FS_P_BLEED_2 FS_P_BLEED_1 VSS ppolyf_u_1k r_width=1u r_length=12.5u
X138 FS_P_BLEED_1 FS_P_BLEED_0 VSS ppolyf_u_1k r_width=1u r_length=12.5u
X139 FS_P_BLEED_0 FS_P_WELL VSS ppolyf_u_1k r_width=1u r_length=12.5u
X140 FS_P_GATE VDD FS_P_WELL FS_P_WELL pfet_03v3 w=4u l=0.28u ad=1.76p as=1.76p pd=8.88u ps=8.88u
X141 FS_P_CONTROL_S VDD VSS VSS nfet_03v3 w=4u l=0.28u ad=1.76p as=1.76p pd=8.88u ps=8.88u
X142 FS_P_GATE FS_HIGH_P FS_P_CONTROL_S VSS nfet_06v0 w=2u l=0.7u ad=0.88p as=0.88p pd=4.88u ps=4.88u
X143 FS_P_OUT FS_P_GATE FS_P_WELL FS_P_WELL pfet_03v3 w=20u l=0.28u ad=8.8p as=8.8p pd=40.88u ps=40.88u
X144 PULLUP_P_OUT PULLUP_P_GATE PULLUP_P_WELL PULLUP_P_WELL pfet_03v3 w=20u l=0.28u ad=8.8p as=8.8p pd=40.88u ps=40.88u
X145 VDD PULLUP_P_GATE PULLUP_P_WELL PULLUP_P_WELL pfet_03v3 w=20u l=0.28u ad=8.8p as=8.8p pd=40.88u ps=40.88u
X146 FS_P_GATE FS_P_BLEED_6 VSS ppolyf_u_1k r_width=1u r_length=12.5u
X147 FS_P_BLEED_6 FS_P_BLEED_5 VSS ppolyf_u_1k r_width=1u r_length=12.5u
X148 FS_P_BLEED_5 FS_P_BLEED_4 VSS ppolyf_u_1k r_width=1u r_length=12.5u
X149 FS_P_BLEED_4 FS_P_BLEED_3 VSS ppolyf_u_1k r_width=1u r_length=12.5u
X150 FS_P_BLEED_3 FS_P_BLEED_2 VSS ppolyf_u_1k r_width=1u r_length=12.5u
X151 PULLUP_P_GATE PULLUP_P PULLUP_P_CONTROL_S VSS nfet_06v0 w=2u l=0.7u ad=0.88p as=0.88p pd=4.88u ps=4.88u
X152 PULLUP_P_OUT PULLUP_P_GATE PULLUP_P_WELL PULLUP_P_WELL pfet_03v3 w=20u l=0.28u ad=8.8p as=8.8p pd=40.88u ps=40.88u
X153 VDD PULLUP_P_GATE PULLUP_P_WELL PULLUP_P_WELL pfet_03v3 w=20u l=0.28u ad=8.8p as=8.8p pd=40.88u ps=40.88u
X154 PULLUP_P_OUT PULLUP_P_GATE PULLUP_P_WELL PULLUP_P_WELL pfet_03v3 w=20u l=0.28u ad=8.8p as=8.8p pd=40.88u ps=40.88u
X155 VDD PULLUP_P_GATE PULLUP_P_WELL PULLUP_P_WELL pfet_03v3 w=20u l=0.28u ad=8.8p as=8.8p pd=40.88u ps=40.88u
X156 PULLUP_P_OUT PULLUP_P_GATE PULLUP_P_WELL PULLUP_P_WELL pfet_03v3 w=20u l=0.28u ad=8.8p as=8.8p pd=40.88u ps=40.88u
X157 VDD PULLUP_P_GATE PULLUP_P_WELL PULLUP_P_WELL pfet_03v3 w=20u l=0.28u ad=8.8p as=8.8p pd=40.88u ps=40.88u
X158 PULLUP_P_BLEED_4 PULLUP_P_BLEED_3 VSS ppolyf_u_1k r_width=1u r_length=12.5u
X159 PULLUP_P_BLEED_3 PULLUP_P_BLEED_2 VSS ppolyf_u_1k r_width=1u r_length=12.5u
X160 PULLUP_P_BLEED_2 PULLUP_P_BLEED_1 VSS ppolyf_u_1k r_width=1u r_length=12.5u
X161 PULLUP_P_BLEED_1 PULLUP_P_BLEED_0 VSS ppolyf_u_1k r_width=1u r_length=12.5u
X162 PULLUP_P_BLEED_0 PULLUP_P_WELL VSS ppolyf_u_1k r_width=1u r_length=12.5u
X163 PULLUP_P_GATE VDD PULLUP_P_WELL PULLUP_P_WELL pfet_03v3 w=4u l=0.28u ad=1.76p as=1.76p pd=8.88u ps=8.88u
X164 PULLUP_P_CONTROL_S VDD VSS VSS nfet_03v3 w=4u l=0.28u ad=1.76p as=1.76p pd=8.88u ps=8.88u
X165 TERM_OR_N_NS VCM_LOW_OK VSS VSS nfet_03v3 w=4u l=0.28u ad=1.76p as=1.76p pd=8.88u ps=8.88u
X166 TERM_OR_N_B FS_LOW_N TERM_OR_N_NS VSS nfet_03v3 w=2u l=0.28u ad=0.88p as=0.88p pd=4.88u ps=4.88u
X167 TERM_OR_N_B TERM_ENABLE VSS VSS nfet_03v3 w=2u l=0.28u ad=0.88p as=0.88p pd=4.88u ps=4.88u
X168 PULLDOWN_P_R PULLDOWN_P VSS VSS nfet_03v3 w=8u l=0.28u ad=3.52p as=3.52p pd=16.88u ps=16.88u
X169 PULLUP_P_GATE PULLUP_P_BLEED_6 VSS ppolyf_u_1k r_width=1u r_length=12.5u
X170 PULLUP_P_BLEED_6 PULLUP_P_BLEED_5 VSS ppolyf_u_1k r_width=1u r_length=12.5u
X171 PULLUP_P_BLEED_5 PULLUP_P_BLEED_4 VSS ppolyf_u_1k r_width=1u r_length=12.5u
X172 TERM_GATE_N_BLEED_1 TERM_GATE_N_BLEED_0 VSS ppolyf_u_1k r_width=1u r_length=12.5u
X173 TERM_GATE_N_BLEED_0 TERM_GATE_N VSS ppolyf_u_1k r_width=1u r_length=12.5u
X174 TERM_GATE_N TERM_OR_N_B VDD VDD pfet_03v3 w=8u l=0.28u ad=3.52p as=3.52p pd=16.88u ps=16.88u
X175 TERM_GATE_N TERM_OR_N_B VSS VSS nfet_03v3 w=4u l=0.28u ad=1.76p as=1.76p pd=8.88u ps=8.88u
X176 TERM_OR_N_B VCM_LOW_OK TERM_OR_N_S VDD pfet_03v3 w=4u l=0.28u ad=1.76p as=1.76p pd=8.88u ps=8.88u
X177 TERM_OR_N_B FS_LOW_N TERM_OR_N_S VDD pfet_03v3 w=4u l=0.28u ad=1.76p as=1.76p pd=8.88u ps=8.88u
X178 TERM_OR_N_S TERM_ENABLE VDD VDD pfet_03v3 w=4u l=0.28u ad=1.76p as=1.76p pd=8.88u ps=8.88u
X179 TERM_N_R TERM_GATE_N TERM_VCM VSS nfet_03v3 w=20u l=0.28u ad=8.8p as=8.8p pd=40.88u ps=40.88u
X180 TERM_N_R TERM_GATE_N TERM_VCM VSS nfet_03v3 w=20u l=0.28u ad=8.8p as=8.8p pd=40.88u ps=40.88u
X181 TERM_N_R TERM_GATE_N TERM_VCM VSS nfet_03v3 w=20u l=0.28u ad=8.8p as=8.8p pd=40.88u ps=40.88u
X182 TERM_N_R TERM_GATE_N TERM_VCM VSS nfet_03v3 w=20u l=0.28u ad=8.8p as=8.8p pd=40.88u ps=40.88u
X183 TERM_N_R TERM_GATE_N TERM_VCM VSS nfet_03v3 w=20u l=0.28u ad=8.8p as=8.8p pd=40.88u ps=40.88u
X184 VSS TERM_GATE_N_BLEED_2 VSS ppolyf_u_1k r_width=1u r_length=12.5u
X185 TERM_GATE_N_BLEED_2 TERM_GATE_N_BLEED_1 VSS ppolyf_u_1k r_width=1u r_length=12.5u
X186 HS_N_1 HS_PBIAS VDD VDD pfet_03v3 w=20u l=1u ad=8.8p as=8.8p pd=40.88u ps=40.88u
X187 HS_N_0 HS_PBIAS VDD VDD pfet_03v3 w=20u l=1u ad=8.8p as=8.8p pd=40.88u ps=40.88u
X188 DIV_LOW_N DIV_ENABLE VSS VSS nfet_03v3 w=20u l=0.28u ad=8.8p as=8.8p pd=40.88u ps=40.88u
X189 DIV_LOW_N DIV_N VSS ppolyf_u_1k r_width=1u r_length=2u
X190 TERM_N_R TERM_GATE_N TERM_VCM VSS nfet_03v3 w=20u l=0.28u ad=8.8p as=8.8p pd=40.88u ps=40.88u
X191 TERM_N_R TERM_GATE_N TERM_VCM VSS nfet_03v3 w=20u l=0.28u ad=8.8p as=8.8p pd=40.88u ps=40.88u
X192 TERM_N_R TERM_GATE_N TERM_VCM VSS nfet_03v3 w=20u l=0.28u ad=8.8p as=8.8p pd=40.88u ps=40.88u
X193 HS_N_8 HS_PBIAS VDD VDD pfet_03v3 w=20u l=1u ad=8.8p as=8.8p pd=40.88u ps=40.88u
X194 HS_N_7 HS_PBIAS VDD VDD pfet_03v3 w=20u l=1u ad=8.8p as=8.8p pd=40.88u ps=40.88u
X195 HS_N_6 HS_PBIAS VDD VDD pfet_03v3 w=20u l=1u ad=8.8p as=8.8p pd=40.88u ps=40.88u
X196 HS_N_5 HS_PBIAS VDD VDD pfet_03v3 w=20u l=1u ad=8.8p as=8.8p pd=40.88u ps=40.88u
X197 HS_N_4 HS_PBIAS VDD VDD pfet_03v3 w=20u l=1u ad=8.8p as=8.8p pd=40.88u ps=40.88u
X198 HS_N_3 HS_PBIAS VDD VDD pfet_03v3 w=20u l=1u ad=8.8p as=8.8p pd=40.88u ps=40.88u
X199 HS_N_2 HS_PBIAS VDD VDD pfet_03v3 w=20u l=1u ad=8.8p as=8.8p pd=40.88u ps=40.88u
X200 FS_N_OUT FS_N_GATE FS_N_WELL FS_N_WELL pfet_03v3 w=20u l=0.28u ad=8.8p as=8.8p pd=40.88u ps=40.88u
X201 VDD FS_N_GATE FS_N_WELL FS_N_WELL pfet_03v3 w=20u l=0.28u ad=8.8p as=8.8p pd=40.88u ps=40.88u
X202 HS_N_13 HS_PBIAS VDD VDD pfet_03v3 w=20u l=1u ad=8.8p as=8.8p pd=40.88u ps=40.88u
X203 HS_N_12 HS_PBIAS VDD VDD pfet_03v3 w=20u l=1u ad=8.8p as=8.8p pd=40.88u ps=40.88u
X204 HS_N_11 HS_PBIAS VDD VDD pfet_03v3 w=20u l=1u ad=8.8p as=8.8p pd=40.88u ps=40.88u
X205 HS_N_10 HS_PBIAS VDD VDD pfet_03v3 w=20u l=1u ad=8.8p as=8.8p pd=40.88u ps=40.88u
X206 HS_N_9 HS_PBIAS VDD VDD pfet_03v3 w=20u l=1u ad=8.8p as=8.8p pd=40.88u ps=40.88u
X207 VDD FS_N_GATE FS_N_WELL FS_N_WELL pfet_03v3 w=20u l=0.28u ad=8.8p as=8.8p pd=40.88u ps=40.88u
X208 FS_N_OUT FS_N_GATE FS_N_WELL FS_N_WELL pfet_03v3 w=20u l=0.28u ad=8.8p as=8.8p pd=40.88u ps=40.88u
X209 VDD FS_N_GATE FS_N_WELL FS_N_WELL pfet_03v3 w=20u l=0.28u ad=8.8p as=8.8p pd=40.88u ps=40.88u
X210 FS_N_OUT FS_N_GATE FS_N_WELL FS_N_WELL pfet_03v3 w=20u l=0.28u ad=8.8p as=8.8p pd=40.88u ps=40.88u
X211 VDD FS_N_GATE FS_N_WELL FS_N_WELL pfet_03v3 w=20u l=0.28u ad=8.8p as=8.8p pd=40.88u ps=40.88u
X212 FS_N_OUT FS_N_GATE FS_N_WELL FS_N_WELL pfet_03v3 w=20u l=0.28u ad=8.8p as=8.8p pd=40.88u ps=40.88u
X213 VDD FS_N_GATE FS_N_WELL FS_N_WELL pfet_03v3 w=20u l=0.28u ad=8.8p as=8.8p pd=40.88u ps=40.88u
X214 FS_N_OUT FS_N_GATE FS_N_WELL FS_N_WELL pfet_03v3 w=20u l=0.28u ad=8.8p as=8.8p pd=40.88u ps=40.88u
X215 VDD FS_N_GATE FS_N_WELL FS_N_WELL pfet_03v3 w=20u l=0.28u ad=8.8p as=8.8p pd=40.88u ps=40.88u
X216 FS_N_OUT FS_N_GATE FS_N_WELL FS_N_WELL pfet_03v3 w=20u l=0.28u ad=8.8p as=8.8p pd=40.88u ps=40.88u
X217 VDD FS_N_GATE FS_N_WELL FS_N_WELL pfet_03v3 w=20u l=0.28u ad=8.8p as=8.8p pd=40.88u ps=40.88u
X218 FS_N_OUT FS_N_GATE FS_N_WELL FS_N_WELL pfet_03v3 w=20u l=0.28u ad=8.8p as=8.8p pd=40.88u ps=40.88u
X219 VDD FS_N_GATE FS_N_WELL FS_N_WELL pfet_03v3 w=20u l=0.28u ad=8.8p as=8.8p pd=40.88u ps=40.88u
X220 FS_N_OUT FS_N_GATE FS_N_WELL FS_N_WELL pfet_03v3 w=20u l=0.28u ad=8.8p as=8.8p pd=40.88u ps=40.88u
X221 VDD FS_N_GATE FS_N_WELL FS_N_WELL pfet_03v3 w=20u l=0.28u ad=8.8p as=8.8p pd=40.88u ps=40.88u
X222 FS_N_OUT FS_N_GATE FS_N_WELL FS_N_WELL pfet_03v3 w=20u l=0.28u ad=8.8p as=8.8p pd=40.88u ps=40.88u
X223 VDD FS_N_GATE FS_N_WELL FS_N_WELL pfet_03v3 w=20u l=0.28u ad=8.8p as=8.8p pd=40.88u ps=40.88u
X224 FS_N_OUT FS_N_GATE FS_N_WELL FS_N_WELL pfet_03v3 w=20u l=0.28u ad=8.8p as=8.8p pd=40.88u ps=40.88u
X225 VDD FS_N_GATE FS_N_WELL FS_N_WELL pfet_03v3 w=20u l=0.28u ad=8.8p as=8.8p pd=40.88u ps=40.88u
X226 FS_N_OUT FS_N_GATE FS_N_WELL FS_N_WELL pfet_03v3 w=20u l=0.28u ad=8.8p as=8.8p pd=40.88u ps=40.88u
X227 VDD FS_N_GATE FS_N_WELL FS_N_WELL pfet_03v3 w=20u l=0.28u ad=8.8p as=8.8p pd=40.88u ps=40.88u
X228 FS_N_OUT FS_N_GATE FS_N_WELL FS_N_WELL pfet_03v3 w=20u l=0.28u ad=8.8p as=8.8p pd=40.88u ps=40.88u
X229 VDD FS_N_GATE FS_N_WELL FS_N_WELL pfet_03v3 w=20u l=0.28u ad=8.8p as=8.8p pd=40.88u ps=40.88u
X230 FS_N_OUT FS_N_GATE FS_N_WELL FS_N_WELL pfet_03v3 w=20u l=0.28u ad=8.8p as=8.8p pd=40.88u ps=40.88u
X231 VDD FS_N_GATE FS_N_WELL FS_N_WELL pfet_03v3 w=20u l=0.28u ad=8.8p as=8.8p pd=40.88u ps=40.88u
X232 FS_N_OUT FS_N_GATE FS_N_WELL FS_N_WELL pfet_03v3 w=20u l=0.28u ad=8.8p as=8.8p pd=40.88u ps=40.88u
X233 VDD FS_N_GATE FS_N_WELL FS_N_WELL pfet_03v3 w=20u l=0.28u ad=8.8p as=8.8p pd=40.88u ps=40.88u
X234 FS_N_OUT FS_N_GATE FS_N_WELL FS_N_WELL pfet_03v3 w=20u l=0.28u ad=8.8p as=8.8p pd=40.88u ps=40.88u
X235 VDD FS_N_GATE FS_N_WELL FS_N_WELL pfet_03v3 w=20u l=0.28u ad=8.8p as=8.8p pd=40.88u ps=40.88u
X236 FS_N_OUT FS_N_GATE FS_N_WELL FS_N_WELL pfet_03v3 w=20u l=0.28u ad=8.8p as=8.8p pd=40.88u ps=40.88u
X237 VDD FS_N_GATE FS_N_WELL FS_N_WELL pfet_03v3 w=20u l=0.28u ad=8.8p as=8.8p pd=40.88u ps=40.88u
X238 FS_N_OUT FS_N_GATE FS_N_WELL FS_N_WELL pfet_03v3 w=20u l=0.28u ad=8.8p as=8.8p pd=40.88u ps=40.88u
X239 VDD FS_N_GATE FS_N_WELL FS_N_WELL pfet_03v3 w=20u l=0.28u ad=8.8p as=8.8p pd=40.88u ps=40.88u
X240 FS_N_OUT FS_N_GATE FS_N_WELL FS_N_WELL pfet_03v3 w=20u l=0.28u ad=8.8p as=8.8p pd=40.88u ps=40.88u
X241 VDD FS_N_GATE FS_N_WELL FS_N_WELL pfet_03v3 w=20u l=0.28u ad=8.8p as=8.8p pd=40.88u ps=40.88u
X242 FS_N_OUT FS_N_GATE FS_N_WELL FS_N_WELL pfet_03v3 w=20u l=0.28u ad=8.8p as=8.8p pd=40.88u ps=40.88u
X243 VDD FS_N_GATE FS_N_WELL FS_N_WELL pfet_03v3 w=20u l=0.28u ad=8.8p as=8.8p pd=40.88u ps=40.88u
X244 FS_N_OUT FS_N_GATE FS_N_WELL FS_N_WELL pfet_03v3 w=20u l=0.28u ad=8.8p as=8.8p pd=40.88u ps=40.88u
X245 VDD FS_N_GATE FS_N_WELL FS_N_WELL pfet_03v3 w=20u l=0.28u ad=8.8p as=8.8p pd=40.88u ps=40.88u
X246 FS_N_OUT FS_N_GATE FS_N_WELL FS_N_WELL pfet_03v3 w=20u l=0.28u ad=8.8p as=8.8p pd=40.88u ps=40.88u
X247 VDD FS_N_GATE FS_N_WELL FS_N_WELL pfet_03v3 w=20u l=0.28u ad=8.8p as=8.8p pd=40.88u ps=40.88u
X248 FS_N_OUT FS_N_GATE FS_N_WELL FS_N_WELL pfet_03v3 w=20u l=0.28u ad=8.8p as=8.8p pd=40.88u ps=40.88u
X249 FS_N_GATE VDD FS_N_WELL FS_N_WELL pfet_03v3 w=4u l=0.28u ad=1.76p as=1.76p pd=8.88u ps=8.88u
X250 FS_N_CONTROL_S VDD VSS VSS nfet_03v3 w=4u l=0.28u ad=1.76p as=1.76p pd=8.88u ps=8.88u
X251 FS_N_GATE FS_HIGH_N FS_N_CONTROL_S VSS nfet_06v0 w=2u l=0.7u ad=0.88p as=0.88p pd=4.88u ps=4.88u
X252 FS_N_OUT FS_N_GATE FS_N_WELL FS_N_WELL pfet_03v3 w=20u l=0.28u ad=8.8p as=8.8p pd=40.88u ps=40.88u
X253 VDD FS_N_GATE FS_N_WELL FS_N_WELL pfet_03v3 w=20u l=0.28u ad=8.8p as=8.8p pd=40.88u ps=40.88u
X254 FS_N_OUT FS_N_GATE FS_N_WELL FS_N_WELL pfet_03v3 w=20u l=0.28u ad=8.8p as=8.8p pd=40.88u ps=40.88u
X255 VDD FS_N_GATE FS_N_WELL FS_N_WELL pfet_03v3 w=20u l=0.28u ad=8.8p as=8.8p pd=40.88u ps=40.88u
X256 FS_N_BLEED_6 FS_N_BLEED_5 VSS ppolyf_u_1k r_width=1u r_length=12.5u
X257 FS_N_BLEED_5 FS_N_BLEED_4 VSS ppolyf_u_1k r_width=1u r_length=12.5u
X258 FS_N_BLEED_4 FS_N_BLEED_3 VSS ppolyf_u_1k r_width=1u r_length=12.5u
X259 FS_N_BLEED_3 FS_N_BLEED_2 VSS ppolyf_u_1k r_width=1u r_length=12.5u
X260 FS_N_BLEED_2 FS_N_BLEED_1 VSS ppolyf_u_1k r_width=1u r_length=12.5u
X261 FS_N_BLEED_1 FS_N_BLEED_0 VSS ppolyf_u_1k r_width=1u r_length=12.5u
X262 FS_N_BLEED_0 FS_N_WELL VSS ppolyf_u_1k r_width=1u r_length=12.5u
X263 PULLUP_N_OUT PULLUP_N_GATE PULLUP_N_WELL PULLUP_N_WELL pfet_03v3 w=20u l=0.28u ad=8.8p as=8.8p pd=40.88u ps=40.88u
X264 VDD PULLUP_N_GATE PULLUP_N_WELL PULLUP_N_WELL pfet_03v3 w=20u l=0.28u ad=8.8p as=8.8p pd=40.88u ps=40.88u
X265 PULLUP_N_OUT PULLUP_N_GATE PULLUP_N_WELL PULLUP_N_WELL pfet_03v3 w=20u l=0.28u ad=8.8p as=8.8p pd=40.88u ps=40.88u
X266 VDD PULLUP_N_GATE PULLUP_N_WELL PULLUP_N_WELL pfet_03v3 w=20u l=0.28u ad=8.8p as=8.8p pd=40.88u ps=40.88u
X267 PULLUP_N_OUT PULLUP_N_GATE PULLUP_N_WELL PULLUP_N_WELL pfet_03v3 w=20u l=0.28u ad=8.8p as=8.8p pd=40.88u ps=40.88u
X268 VDD PULLUP_N_GATE PULLUP_N_WELL PULLUP_N_WELL pfet_03v3 w=20u l=0.28u ad=8.8p as=8.8p pd=40.88u ps=40.88u
X269 FS_N_GATE FS_N_BLEED_6 VSS ppolyf_u_1k r_width=1u r_length=12.5u
X270 PULLUP_N_BLEED_1 PULLUP_N_BLEED_0 VSS ppolyf_u_1k r_width=1u r_length=12.5u
X271 PULLUP_N_BLEED_0 PULLUP_N_WELL VSS ppolyf_u_1k r_width=1u r_length=12.5u
X272 PULLUP_N_GATE VDD PULLUP_N_WELL PULLUP_N_WELL pfet_03v3 w=4u l=0.28u ad=1.76p as=1.76p pd=8.88u ps=8.88u
X273 PULLUP_N_CONTROL_S VDD VSS VSS nfet_03v3 w=4u l=0.28u ad=1.76p as=1.76p pd=8.88u ps=8.88u
X274 PULLUP_N_GATE PULLUP_N PULLUP_N_CONTROL_S VSS nfet_06v0 w=2u l=0.7u ad=0.88p as=0.88p pd=4.88u ps=4.88u
X275 PULLUP_N_OUT PULLUP_N_GATE PULLUP_N_WELL PULLUP_N_WELL pfet_03v3 w=20u l=0.28u ad=8.8p as=8.8p pd=40.88u ps=40.88u
X276 VDD PULLUP_N_GATE PULLUP_N_WELL PULLUP_N_WELL pfet_03v3 w=20u l=0.28u ad=8.8p as=8.8p pd=40.88u ps=40.88u
X277 PULLDOWN_N_R PULLDOWN_N VSS VSS nfet_03v3 w=8u l=0.28u ad=3.52p as=3.52p pd=16.88u ps=16.88u
X278 PULLUP_N_GATE PULLUP_N_BLEED_6 VSS ppolyf_u_1k r_width=1u r_length=12.5u
X279 PULLUP_N_BLEED_6 PULLUP_N_BLEED_5 VSS ppolyf_u_1k r_width=1u r_length=12.5u
X280 PULLUP_N_BLEED_5 PULLUP_N_BLEED_4 VSS ppolyf_u_1k r_width=1u r_length=12.5u
X281 PULLUP_N_BLEED_4 PULLUP_N_BLEED_3 VSS ppolyf_u_1k r_width=1u r_length=12.5u
X282 PULLUP_N_BLEED_3 PULLUP_N_BLEED_2 VSS ppolyf_u_1k r_width=1u r_length=12.5u
X283 PULLUP_N_BLEED_2 PULLUP_N_BLEED_1 VSS ppolyf_u_1k r_width=1u r_length=12.5u
X284 TERM_P_R DIFF_ENABLE TERM_N_R VSS nfet_03v3 w=20u l=0.28u ad=8.8p as=8.8p pd=40.88u ps=40.88u
X285 TERM_P_R DIFF_ENABLE TERM_N_R VSS nfet_03v3 w=20u l=0.28u ad=8.8p as=8.8p pd=40.88u ps=40.88u
X286 TERM_P_R DIFF_ENABLE TERM_N_R VSS nfet_03v3 w=20u l=0.28u ad=8.8p as=8.8p pd=40.88u ps=40.88u
X287 TERM_P_R DIFF_ENABLE TERM_N_R VSS nfet_03v3 w=20u l=0.28u ad=8.8p as=8.8p pd=40.88u ps=40.88u
X288 TERM_P_R DIFF_ENABLE TERM_N_R VSS nfet_03v3 w=20u l=0.28u ad=8.8p as=8.8p pd=40.88u ps=40.88u
C12 RX_N VSS 3.49842e-14
C13 RX_P VSS 3.55022e-14
C14 BYPASS_ENABLE VSS 6.04887e-14
C15 HS_N VSS 5.64168e-14
C16 HS_P VSS 4.06958e-14
C22 PAD_P VSS 2.67795e-13
C24 PAD_N VSS 2.82279e-13
C25 TERM_OR_P_S VSS 3.53275e-15
C26 TERM_OR_P_NS VSS 1.00639e-14
C27 FS_LOW_P VSS 3.74596e-14
C29 TERM_GATE_P_BLEED_2 VSS 3.28565e-15
C31 TERM_GATE_P_BLEED_1 VSS 5.10072e-15
C33 TERM_GATE_P_BLEED_0 VSS 7.68181e-15
C35 TERM_OR_P_B VSS 2.1153e-14
C36 TERM_GATE_P VSS 2.7029e-14
C37 HS_P_4 VSS 7.08832e-15
C38 HS_P_3 VSS 7.10747e-15
C39 HS_P_2 VSS 6.92882e-15
C40 HS_P_1 VSS 5.64847e-15
C41 HS_P_0 VSS 7.04651e-15
C42 DIV_LOW_P VSS 7.23693e-15
C44 DIV_P VSS 1.41199e-14
C45 HS_P_11 VSS 8.66747e-15
C46 HS_P_10 VSS 6.56279e-15
C47 HS_P_9 VSS 7.07185e-15
C48 HS_P_8 VSS 5.68774e-15
C49 HS_P_7 VSS 4.83647e-15
C50 HS_P_6 VSS 5.96197e-15
C51 HS_P_5 VSS 7.82831e-15
C52 HS_P_13 VSS 6.12402e-15
C53 HS_P_12 VSS 7.61219e-15
C55 FS_P_BLEED_1 VSS 5.43542e-15
C57 FS_P_BLEED_0 VSS 4.65426e-15
C59 FS_P_CONTROL_S VSS 4.50389e-15
C60 FS_HIGH_P VSS 6.50745e-15
C61 FS_P_OUT VSS 3.32442e-14
C62 FS_P_GATE VSS 5.41783e-14
C64 FS_P_BLEED_6 VSS 4.11494e-15
C66 FS_P_BLEED_5 VSS 3.49709e-15
C68 FS_P_BLEED_4 VSS 3.14909e-15
C70 FS_P_BLEED_3 VSS 3.74647e-15
C72 FS_P_BLEED_2 VSS 8.07498e-15
C73 PULLUP_P VSS 2.03883e-14
C74 PULLUP_P_OUT VSS 1.96243e-14
C76 PULLUP_P_BLEED_3 VSS 4.19605e-15
C78 PULLUP_P_BLEED_2 VSS 3.20038e-15
C80 PULLUP_P_BLEED_1 VSS 3.21015e-15
C82 PULLUP_P_BLEED_0 VSS 5.16157e-15
C84 PULLUP_P_CONTROL_S VSS 6.8319e-15
C85 TERM_OR_N_NS VSS 4.57594e-15
C86 PULLDOWN_P_R VSS 2.08088e-14
C87 PULLDOWN_P VSS 1.31543e-14
C88 PULLUP_P_GATE VSS 2.03626e-14
C90 PULLUP_P_BLEED_6 VSS 8.95891e-15
C92 PULLUP_P_BLEED_5 VSS 1.1915e-14
C94 PULLUP_P_BLEED_4 VSS 8.3128e-15
C96 TERM_GATE_N_BLEED_0 VSS 3.57556e-15
C98 VCM_LOW_OK VSS 1.83232e-14
C99 TERM_OR_N_B VSS 1.05695e-14
C100 FS_LOW_N VSS 8.93361e-15
C101 TERM_OR_N_S VSS 5.67983e-15
C102 TERM_ENABLE VSS 5.0405e-14
C104 TERM_GATE_N_BLEED_2 VSS 1.90723e-14
C106 TERM_GATE_N_BLEED_1 VSS 8.32567e-15
C107 HS_N_1 VSS 1.08501e-14
C108 HS_N_0 VSS 1.15295e-14
C109 DIV_ENABLE VSS 2.24643e-14
C110 DIV_LOW_N VSS 7.76443e-15
C112 DIV_N VSS 1.81827e-14
C113 TERM_VCM VSS 1.14924e-13
C114 TERM_GATE_N VSS 1.61058e-14
C115 HS_N_8 VSS 9.46099e-15
C116 HS_N_7 VSS 8.02904e-15
C117 HS_N_6 VSS 8.95529e-15
C118 HS_N_5 VSS 8.3131e-15
C119 HS_N_4 VSS 7.38871e-15
C120 HS_N_3 VSS 7.80958e-15
C121 HS_N_2 VSS 9.75543e-15
C122 HS_N_13 VSS 8.71447e-15
C123 HS_N_12 VSS 9.8184e-15
C124 HS_N_11 VSS 9.16153e-15
C125 HS_N_10 VSS 8.85948e-15
C126 HS_N_9 VSS 9.6176e-15
C127 HS_PBIAS VSS 4.92916e-14
C128 FS_N_CONTROL_S VSS 5.47781e-15
C129 FS_HIGH_N VSS 3.64763e-15
C130 FS_N_OUT VSS 6.69278e-14
C132 FS_N_BLEED_5 VSS 5.98437e-15
C134 FS_N_BLEED_4 VSS 4.95494e-15
C136 FS_N_BLEED_3 VSS 4.38381e-15
C138 FS_N_BLEED_2 VSS 3.88023e-15
C140 FS_N_BLEED_1 VSS 3.51417e-15
C142 FS_N_BLEED_0 VSS 3.2728e-15
C144 FS_N_GATE VSS 5.766e-14
C146 FS_N_BLEED_6 VSS 8.07787e-15
C148 PULLUP_N_BLEED_0 VSS 4.40025e-15
C150 PULLUP_N_CONTROL_S VSS 4.58281e-15
C151 PULLUP_N VSS 3.16543e-15
C152 PULLUP_N_OUT VSS 4.42339e-14
C153 PULLDOWN_N_R VSS 3.63785e-14
C154 PULLDOWN_N VSS 5.09355e-15
C155 PULLUP_N_GATE VSS 1.27893e-14
C157 PULLUP_N_BLEED_6 VSS 3.40901e-15
C159 PULLUP_N_BLEED_5 VSS 3.00905e-15
C161 PULLUP_N_BLEED_4 VSS 4.15562e-15
C163 PULLUP_N_BLEED_3 VSS 6.97404e-15
C165 PULLUP_N_BLEED_2 VSS 9.92042e-15
C167 PULLUP_N_BLEED_1 VSS 8.17871e-15
C168 TERM_P_R VSS 9.55265e-14
C169 TERM_N_R VSS 1.19378e-13
C170 DIFF_ENABLE VSS 1.42385e-14
C171 FS_P_WELL VSS 5.41093e-13
C172 PULLUP_P_WELL VSS 9.66713e-14
C173 VDD VSS 7.30519e-13
C174 FS_N_WELL VSS 5.52665e-13
C175 PULLUP_N_WELL VSS 9.51067e-14
C176 FS_P_BLEED_2 FS_N_OUT 2.78894e-16
C177 VDD FS_P_BLEED_6 1.1762e-18
C178 TERM_GATE_N_BLEED_2 FS_LOW_P 5.87202e-17
C179 HS_PBIAS VCM_LOW_OK 4.04793e-16
C180 DIV_N PULLUP_P_CONTROL_S 4.31015e-19
C181 PULLUP_P_BLEED_4 BYPASS_ENABLE 7.65665e-18
C182 HS_N_1 FS_P_BLEED_4 2.93773e-17
C183 HS_N_5 PULLUP_P_WELL 1.7988e-16
C184 PULLUP_N_OUT PULLUP_P_GATE 2.9848e-16
C185 DIV_LOW_N FS_N_OUT 1.1535e-16
C186 HS_P_10 TERM_OR_P_NS 4.32898e-17
C187 HS_P_8 PAD_N 8.55121e-16
C188 PULLUP_N_BLEED_6 PULLUP_N_BLEED_5 1.37599e-15
C189 PULLDOWN_N_R PULLUP_N_BLEED_4 8.99691e-17
C190 HS_P_2 TERM_GATE_P 1.57176e-16
C191 HS_N_0 PULLUP_P_OUT 2.6893e-17
C192 TERM_ENABLE PULLUP_P_BLEED_5 6.98984e-19
C193 FS_P_OUT RX_N 5.05342e-18
C194 PULLDOWN_N_R FS_LOW_N 5.91326e-17
C195 HS_N_11 TERM_GATE_N_BLEED_1 3.48887e-17
C196 HS_N_9 TERM_OR_N_S 7.33658e-17
C197 HS_N_2 TERM_N_R 6.24464e-17
C198 PULLUP_N_GATE TERM_ENABLE 2.30355e-16
C199 FS_N_BLEED_0 HS_N 2.11753e-17
C200 HS_P_7 HS_P_0 4.6889e-18
C201 VDD PULLUP_N_BLEED_1 4.56068e-16
C202 FS_P_BLEED_2 HS_N_2 3.47206e-17
C203 PAD_P HS_P_11 1.25724e-15
C204 TERM_GATE_N_BLEED_1 FS_LOW_P 6.27135e-17
C205 TERM_N_R PULLUP_P_CONTROL_S 6.05784e-17
C206 HS_P_6 TERM_OR_P_B 1.01328e-16
C207 TERM_OR_N_B PULLDOWN_P 8.71322e-17
C208 PULLUP_P_BLEED_0 PULLDOWN_P_R 1.24089e-16
C209 HS_N_4 PULLUP_P_BLEED_6 2.90558e-17
C210 TERM_VCM HS_P_3 1.20188e-16
C211 DIFF_ENABLE BYPASS_ENABLE 6.50064e-15
C212 FS_N_WELL PULLDOWN_P 2.85309e-15
C213 HS_P HS_P_13 7.10071e-16
C214 PULLDOWN_N_R PAD_N 4.48191e-15
C215 FS_P_GATE FS_HIGH_P 4.36375e-16
C216 HS_N_8 TERM_GATE_P 1.28047e-16
C217 HS_N_13 TERM_GATE_N_BLEED_2 5.2499e-17
C218 DIV_N HS_N_4 3.31088e-17
C219 DIV_LOW_N HS_N_2 6.1779e-17
C220 HS_N_5 TERM_VCM 1.27528e-16
C221 HS_N_7 HS_N_8 1.19047e-13
C222 HS_N_11 TERM_ENABLE 4.83039e-17
C223 TERM_GATE_N HS_N_6 5.14347e-17
C224 VDD FS_HIGH_P 8.36822e-16
C225 HS_N_1 HS_P_13 1.21554e-16
C226 TERM_ENABLE FS_LOW_P 2.00401e-16
C227 PULLDOWN_P PULLUP_P_GATE 3.88276e-17
C228 PULLUP_N_GATE PULLUP_N_BLEED_4 1.03866e-16
C229 HS_P_10 PAD_N 4.24765e-16
C230 VDD FS_N_GATE 2.72268e-14
C231 HS_N_7 PULLUP_P_WELL 1.90177e-16
C232 HS_N_4 TERM_N_R 5.89263e-17
C233 HS_N_9 TERM_OR_N_B 2.88924e-17
C234 FS_LOW_N PULLUP_P_BLEED_5 8.29838e-17
C235 HS_N_0 FS_P_BLEED_3 6.61586e-19
C236 HS_N_13 TERM_GATE_N_BLEED_1 3.48887e-17
C237 FS_N_BLEED_4 FS_LOW_P 8.10079e-17
C238 FS_LOW_P TERM_OR_P_NS 3.97232e-16
C239 PULLUP_N_BLEED_6 TERM_ENABLE 8.9543e-17
C240 PULLUP_N_GATE FS_LOW_N 9.32886e-17
C241 PULLUP_N HS_P 1.90282e-18
C242 PULLUP_P_BLEED_2 PULLUP_P_GATE 2.04956e-16
C243 FS_P_BLEED_2 HS_N_4 3.47206e-17
C244 DIV_N HS_P_12 1.24604e-17
C245 FS_P_OUT FS_P_WELL 2.1037e-13
C246 TERM_GATE_P_BLEED_0 PULLDOWN_P_R 1.24089e-16
C247 TERM_P_R PULLUP_P 2.69783e-16
C248 FS_P_GATE PULLDOWN_P_R 1.5993e-15
C249 HS_N_6 PULLUP_P_BLEED_6 3.30612e-17
C250 VDD PULLDOWN_P_R 1.96881e-15
C251 TERM_VCM TERM_GATE_P 2.64481e-14
C252 HS_N_3 TERM_GATE_N_BLEED_2 5.2499e-17
C253 DIV_N HS_N_6 3.31088e-17
C254 DIV_LOW_N HS_N_4 6.1779e-17
C255 HS_N_7 TERM_VCM 1.84464e-16
C256 HS_N_13 TERM_ENABLE 8.85304e-17
C257 HS_P HS_P_8 3.0077e-15
C258 TERM_GATE_N HS_N_8 5.3859e-17
C259 HS_N_11 FS_LOW_N 4.60726e-17
C260 HS_N_9 PULLUP_P_GATE 7.72446e-17
C261 PULLUP_N_OUT DIV_ENABLE 5.06175e-17
C262 FS_HIGH_N PULLUP_P 4.37656e-17
C263 FS_LOW_N FS_LOW_P 9.39795e-14
C264 FS_N_BLEED_6 FS_N_BLEED_2 7.62796e-18
C265 HS_P_5 PULLDOWN_P_R 2.40376e-17
C266 PULLUP_N_BLEED_6 PULLUP_N_BLEED_4 1.53063e-19
C267 DIV_P PAD_N 4.74805e-16
C268 HS_N_0 FS_P_BLEED_5 6.1779e-17
C269 HS_N_11 PAD_N 1.22201e-15
C270 PULLUP_N_OUT VCM_LOW_OK 1.5823e-16
C271 HS_N_3 TERM_GATE_N_BLEED_1 3.48887e-17
C272 HS_N_6 TERM_N_R 5.89263e-17
C273 TERM_P_R FS_P_BLEED_1 1.09344e-16
C274 FS_P_GATE HS_N 2.28325e-15
C275 PULLDOWN_N_R HS_P 4.19789e-17
C276 VCM_LOW_OK TERM_OR_N_NS 2.03294e-15
C277 VDD HS_N 2.63614e-15
C278 FS_P_BLEED_2 HS_N_6 3.47206e-17
C279 HS_P FS_P_BLEED_0 6.1779e-17
C280 PULLDOWN_N_R HS_N_1 6.83199e-17
C281 HS_PBIAS HS_P_9 3.39603e-15
C282 HS_N_1 FS_P_BLEED_0 6.1779e-17
C283 HS_N_8 PULLUP_P_BLEED_6 4.18833e-17
C284 TERM_ENABLE HS_P_1 2.40376e-17
C285 HS_N HS_P_5 3.9228e-16
C286 HS_P HS_P_10 2.44809e-15
C287 PAD_P PULLUP_P_OUT 4.38071e-16
C288 HS_P_4 PULLDOWN_P_R 7.46551e-17
C289 HS_N_13 FS_LOW_N 4.57398e-17
C290 HS_N_3 TERM_ENABLE 4.80752e-17
C291 HS_N_5 TERM_GATE_N_BLEED_2 5.2499e-17
C292 DIV_N HS_N_8 3.31088e-17
C293 DIV_LOW_N HS_N_6 6.1779e-17
C294 DIV_ENABLE PULLDOWN_P 4.42824e-17
C295 TERM_GATE_N TERM_VCM 2.64092e-14
C296 HS_N_1 HS_P_10 3.47966e-17
C297 FS_N_BLEED_6 FS_N_BLEED_1 7.62796e-18
C298 TERM_P_R HS_P_0 7.62563e-17
C299 HS_P_1 TERM_OR_P_NS 4.31214e-17
C300 DIV_N PULLUP_P_WELL 8.03831e-17
C301 PULLUP_N_BLEED_3 PULLUP_N_BLEED_5 6.56802e-17
C302 VCM_LOW_OK PULLDOWN_P 3.74305e-17
C303 HS_N_3 TERM_OR_P_NS 1.52957e-18
C304 HS_N_13 PAD_N 1.56314e-15
C305 HS_N_10 FS_P_BLEED_1 6.1779e-17
C306 HS_N_0 FS_P_BLEED_6 6.1779e-17
C307 HS_P PULLUP_P_BLEED_5 5.2499e-17
C308 HS_N_8 TERM_N_R 1.16571e-16
C309 HS_N_5 TERM_GATE_N_BLEED_1 3.48887e-17
C310 PULLUP_N_GATE HS_P 1.18496e-16
C311 PULLUP_N_OUT PULLUP_P_BLEED_1 4.64285e-17
C312 HS_N_1 PULLUP_P_BLEED_5 5.28587e-17
C313 FS_P_BLEED_2 HS_N_8 3.47206e-17
C314 HS_N_9 DIV_ENABLE 3.08895e-17
C315 HS_N_12 PULLUP_P 6.95504e-19
C316 HS_N HS_P_4 1.58774e-16
C317 FS_N_BLEED_2 FS_N_WELL 1.07552e-18
C318 TERM_N_R PULLUP_P_WELL 3.32612e-16
C319 PULLUP_P_BLEED_4 PULLUP_P_GATE 2.77879e-16
C320 VCM_LOW_OK PULLUP_P_BLEED_2 1.46249e-17
C321 TERM_N_R FS_N_BLEED_5 1.14443e-16
C322 TERM_ENABLE HS_P_3 7.67984e-17
C323 PULLDOWN_N_R FS_N_BLEED_3 9.11073e-17
C324 HS_N_3 FS_LOW_N 4.57398e-17
C325 HS_N_5 TERM_ENABLE 4.80752e-17
C326 HS_N_7 TERM_GATE_N_BLEED_2 5.2499e-17
C327 DIV_LOW_N HS_N_8 6.1779e-17
C328 HS_N_11 HS_P 7.64555e-16
C329 HS_P DIV_P 8.00466e-17
C330 DIV_N TERM_VCM 7.23097e-16
C331 FS_P_BLEED_2 PULLUP_P_WELL 5.42183e-18
C332 FS_P_GATE FS_P_BLEED_4 2.93237e-16
C333 FS_N_OUT PULLUP_P 4.66023e-16
C334 VDD FS_P_BLEED_4 2.57363e-18
C335 HS_N_9 VCM_LOW_OK 3.62369e-17
C336 HS_N_11 HS_N_1 7.58432e-17
C337 HS_N_10 HS_P_0 6.98931e-17
C338 HS_P FS_LOW_P 9.86342e-17
C339 HS_P_3 TERM_OR_P_NS 2.84614e-17
C340 HS_N_1 FS_LOW_P 8.50523e-17
C341 HS_N_5 TERM_OR_P_NS 2.58302e-18
C342 HS_N_3 PAD_N 1.66755e-15
C343 HS_P_1 PAD_N 5.67156e-16
C344 PULLUP_N_BLEED_2 PULLUP_N_BLEED_5 2.51934e-18
C345 HS_N_12 FS_P_BLEED_1 6.1779e-17
C346 HS_N_0 FS_HIGH_P 3.42328e-19
C347 HS_N_7 TERM_GATE_N_BLEED_1 3.48887e-17
C348 TERM_VCM TERM_N_R 1.74845e-14
C349 FS_P_BLEED_2 TERM_VCM 3.47206e-17
C350 FS_N_BLEED_1 FS_N_WELL 4.54977e-18
C351 FS_N_OUT FS_P_BLEED_1 1.44632e-16
C352 PULLUP_P_BLEED_1 PULLUP_P_BLEED_2 7.61291e-16
C353 PULLUP_P_CONTROL_S PULLUP_P 3.928e-15
C354 TERM_GATE_P_BLEED_0 HS_P_13 2.56002e-17
C355 HS_N_5 FS_LOW_N 4.57398e-17
C356 HS_N_7 TERM_ENABLE 1.03322e-16
C357 DIV_LOW_N TERM_VCM 3.29961e-16
C358 TERM_GATE_N TERM_GATE_N_BLEED_2 4.06393e-16
C359 FS_P_GATE HS_P_13 2.47794e-16
C360 TERM_ENABLE TERM_GATE_P 1.60491e-15
C361 PULLUP_N_OUT HS_P_9 7.92848e-17
C362 HS_N_13 HS_P 1.05194e-16
C363 VDD HS_P_13 6.65527e-15
C364 HS_N_12 HS_P_0 4.37776e-17
C365 HS_N_13 HS_N_1 9.08543e-17
C366 HS_N_1 DIV_LOW_P 3.76364e-18
C367 VCM_LOW_OK HS_P_11 6.67267e-17
C368 HS_P_3 PAD_N 2.56999e-16
C369 HS_N_0 PULLDOWN_P_R 2.50839e-17
C370 PULLUP_N_BLEED_3 PULLUP_N_BLEED_4 2.05029e-15
C371 HS_P_5 HS_P_13 2.69283e-16
C372 HS_N_7 TERM_OR_P_NS 4.91469e-18
C373 PULLUP_N_BLEED_1 BYPASS_ENABLE 7.65665e-18
C374 HS_N_5 PAD_N 1.1645e-15
C375 PULLUP_P_OUT PULLUP_P_GATE 1.83667e-14
C376 HS_N_2 FS_P_BLEED_1 6.1779e-17
C377 FS_N_BLEED_3 FS_LOW_P 1.03866e-16
C378 PULLDOWN_N_R PULLUP_P_BLEED_0 5.77908e-17
C379 TERM_GATE_N TERM_GATE_N_BLEED_1 5.63118e-16
C380 DIV_ENABLE PULLUP_P_BLEED_4 1.37454e-17
C381 PULLUP_N VDD 1.61919e-17
C382 PULLUP_N_OUT TERM_OR_P_B 2.07717e-16
C383 FS_HIGH_P BYPASS_ENABLE 7.62967e-20
C384 TERM_GATE_P_BLEED_0 HS_P_8 2.71033e-17
C385 VCM_LOW_OK PULLUP_P_BLEED_4 3.80972e-17
C386 HS_N_7 FS_LOW_N 4.57398e-17
C387 FS_P_OUT TERM_P_R 4.32318e-16
C388 HS_N_3 HS_P 1.78669e-16
C389 HS_P HS_P_1 4.17406e-15
C390 HS_N_0 HS_N 1.34018e-13
C391 DIV_N TERM_GATE_N_BLEED_2 6.00678e-19
C392 TERM_GATE_N TERM_ENABLE 1.07923e-14
C393 VDD PULLUP_P_BLEED_3 5.24075e-16
C394 VDD HS_P_8 5.00579e-15
C395 HS_P_4 HS_P_13 1.44632e-16
C396 HS_N_1 HS_P_1 9.06571e-17
C397 FS_N_BLEED_0 FS_LOW_P 8.35148e-16
C398 HS_N_2 HS_P_0 3.72247e-17
C399 HS_N_3 HS_N_1 8.22555e-17
C400 TERM_P_R FS_P_WELL 1.45352e-15
C401 DIFF_ENABLE DIV_ENABLE 6.75692e-15
C402 HS_P_5 HS_P_8 1.05682e-18
C403 HS_N_7 PAD_N 1.7635e-15
C404 PULLUP_N_BLEED_2 PULLUP_N_BLEED_4 3.26487e-18
C405 HS_N_4 FS_P_BLEED_1 6.1779e-17
C406 TERM_GATE_P_BLEED_0 PULLDOWN_N_R 5.53044e-17
C407 PULLUP_P_BLEED_5 PULLUP_P_BLEED_0 5.4639e-19
C408 FS_P_BLEED_3 PULLUP_P_GATE 4.70063e-19
C409 PULLUP_N_BLEED_2 FS_LOW_N 8.38863e-17
C410 DIV_N TERM_GATE_N_BLEED_1 1.0151e-16
C411 TERM_GATE_N_BLEED_2 TERM_N_R 1.15649e-16
C412 PULLDOWN_N_R FS_P_GATE 1.44476e-15
C413 FS_P_GATE FS_P_BLEED_0 2.21834e-16
C414 PULLDOWN_N_R VDD 3.41738e-15
C415 HS_N_6 PULLUP_P 4.37656e-17
C416 HS_N_9 HS_P_9 6.70368e-17
C417 VDD FS_P_BLEED_0 2.50257e-16
C418 TERM_ENABLE PULLUP_P_BLEED_6 7.5456e-19
C419 TERM_GATE_P_BLEED_0 HS_P_10 3.77659e-17
C420 PULLDOWN_N_R HS_P_5 2.41139e-17
C421 FS_P_OUT HS_N_10 4.42486e-16
C422 HS_P HS_P_3 1.89056e-15
C423 TERM_GATE_N FS_LOW_N 9.03544e-17
C424 DIV_N TERM_ENABLE 1.34827e-18
C425 TERM_N_R TERM_GATE_N_BLEED_1 2.01079e-16
C426 VDD HS_P_10 6.63844e-15
C427 HS_N_5 HS_P 8.71868e-16
C428 PULLUP_P_BLEED_1 PULLUP_P_BLEED_4 7.80014e-18
C429 HS_P_4 HS_P_8 3.12002e-17
C430 HS_N_1 HS_P_3 2.59854e-17
C431 HS_N_5 HS_N_1 4.30193e-17
C432 HS_N_4 HS_P_0 3.43222e-17
C433 HS_N_10 FS_P_WELL 2.04554e-15
C434 HS_P_5 HS_P_10 4.80989e-17
C435 HS_N BYPASS_ENABLE 1.04923e-17
C436 FS_P_BLEED_5 PULLUP_P_GATE 4.70063e-19
C437 HS_N_6 FS_P_BLEED_1 6.1779e-17
C438 HS_N_9 TERM_OR_P_B 7.25438e-17
C439 TERM_ENABLE TERM_N_R 5.47295e-16
C440 FS_N_OUT RX_N 1.56572e-17
C441 HS_N_0 FS_P_BLEED_4 2.97265e-17
C442 VCM_LOW_OK PULLUP_P_OUT 2.0686e-16
C443 PULLUP_N_BLEED_3 HS_P 1.17851e-16
C444 HS_PBIAS HS_P_6 2.09103e-15
C445 PULLUP_N_GATE VDD 1.22976e-14
C446 FS_N_BLEED_6 FS_HIGH_P 9.40718e-17
C447 PULLDOWN_N_R HS_P_4 7.21687e-17
C448 FS_P_BLEED_2 TERM_ENABLE 5.902e-17
C449 HS_N_8 PULLUP_P 5.06175e-17
C450 HS_P_12 HS_P_0 8.89903e-17
C451 TERM_N_R FS_N_BLEED_4 5.72918e-17
C452 HS_P_9 HS_P_11 8.16518e-18
C453 FS_LOW_N PULLUP_P_BLEED_6 8.29838e-17
C454 PAD_P PULLDOWN_P_R 2.92129e-15
C455 FS_N_BLEED_6 FS_N_GATE 1.43361e-15
C456 TERM_N_R TERM_OR_P_NS 1.01098e-16
C457 TERM_OR_N_S FS_HIGH_P 3.69142e-18
C458 FS_P_OUT HS_N_12 4.38013e-16
C459 DIV_N FS_LOW_N 3.54305e-17
C460 TERM_P_R HS_P_7 8.3435e-17
C461 DIV_LOW_N TERM_ENABLE 4.51263e-17
C462 PULLUP_P_WELL PULLUP_P 4.11378e-16
C463 HS_N_7 HS_P 3.34579e-16
C464 HS_N_11 FS_P_GATE 1.01933e-15
C465 HS_P TERM_GATE_P 2.26214e-16
C466 FS_N_BLEED_5 PULLUP_P 1.01235e-16
C467 VDD DIV_P 1.11676e-16
C468 HS_N_11 VDD 6.23992e-15
C469 HS_P_4 HS_P_10 2.82661e-19
C470 DIV_ENABLE FS_P_BLEED_3 2.67272e-19
C471 FS_P_GATE FS_LOW_P 4.81147e-16
C472 HS_N_1 TERM_GATE_P 1.09739e-16
C473 HS_N_6 HS_P_0 3.7366e-17
C474 HS_N_7 HS_N_1 7.3898e-17
C475 VDD FS_LOW_P 4.01833e-15
C476 HS_N_12 FS_P_WELL 1.97719e-15
C477 FS_P_OUT FS_N_OUT 1.00131e-15
C478 DIV_N PAD_N 6.88592e-16
C479 HS_N_11 HS_P_5 3.48887e-17
C480 HS_N_8 FS_P_BLEED_1 6.1779e-17
C481 HS_N_0 HS_P_13 2.66122e-17
C482 FS_P_BLEED_6 PULLUP_P_GATE 6.11597e-17
C483 FS_LOW_N TERM_N_R 1.91325e-16
C484 HS_N PAD_P 1.2387e-15
C485 PULLUP_N_BLEED_2 HS_P 7.92848e-17
C486 HS_P_11 TERM_OR_P_B 1.19377e-16
C487 HS_P_0 HS_P_2 4.31219e-18
C488 HS_P_5 FS_LOW_P 1.73406e-16
C489 FS_N_OUT FS_P_WELL 9.51456e-16
C490 PULLUP_N_BLEED_6 VDD 1.56976e-17
C491 TERM_VCM PULLUP_P 2.42866e-16
C492 PULLUP_P_WELL FS_P_BLEED_1 6.74983e-19
C493 TERM_N_R PAD_N 8.9086e-17
C494 DIV_LOW_N FS_LOW_N 6.1779e-17
C495 FS_P_OUT HS_N_2 4.35755e-16
C496 HS_N_13 FS_P_GATE 1.01205e-15
C497 HS_PBIAS PULLUP_N_WELL 4.6702e-16
C498 TERM_GATE_N HS_P 5.93302e-17
C499 HS_N_13 VDD 6.77268e-15
C500 FS_N_WELL FS_HIGH_P 1.84613e-15
C501 FS_N_BLEED_6 HS_N 6.15064e-17
C502 HS_N_8 HS_P_0 3.52283e-17
C503 TERM_GATE_N HS_N_1 5.20551e-17
C504 FS_N_CONTROL_S HS_PBIAS 9.19309e-17
C505 HS_N_2 FS_P_WELL 1.92332e-15
C506 PULLUP_N_BLEED_0 PULLUP_N_WELL 2.56376e-15
C507 HS_P_4 FS_LOW_P 4.59929e-17
C508 TERM_OR_P_B TERM_GATE_P_BLEED_1 3.71e-18
C509 HS_P_5 DIV_LOW_P 3.04895e-18
C510 FS_N_WELL FS_N_GATE 2.95433e-13
C511 FS_HIGH_P PULLUP_P_GATE 2.64516e-17
C512 HS_N_13 HS_P_5 3.48887e-17
C513 TERM_OR_N_S HS_N 1.12454e-16
C514 TERM_VCM FS_P_BLEED_1 8.8022e-17
C515 TERM_GATE_P_BLEED_0 HS_P_1 5.5249e-17
C516 PULLUP_N_OUT HS_P_6 2.84614e-17
C517 FS_P_OUT HS_N_4 4.33306e-16
C518 HS_P PULLUP_P_BLEED_6 1.02136e-16
C519 HS_N_3 FS_P_GATE 1.011e-15
C520 DIV_N HS_P 3.58115e-17
C521 HS_N_5 PULLUP_P_BLEED_0 3.33636e-19
C522 HS_N_0 PULLDOWN_N_R 6.83199e-17
C523 VDD HS_P_1 5.548e-15
C524 HS_N_3 VDD 5.42969e-15
C525 HS_N_1 PULLUP_P_BLEED_6 2.45138e-17
C526 HS_N_0 FS_P_BLEED_0 6.1779e-17
C527 HS_P_9 PULLUP_P_OUT 6.89716e-17
C528 PULLUP_N_CONTROL_S PULLUP_N_WELL 8.37127e-17
C529 TERM_VCM HS_P_0 1.95376e-16
C530 DIV_N HS_N_1 3.45142e-17
C531 HS_N_4 FS_P_WELL 1.94169e-15
C532 PULLDOWN_P_R PULLUP_P_GATE 2.4897e-16
C533 HS_P_5 HS_P_1 2.41139e-17
C534 HS_N_3 HS_P_5 3.48887e-17
C535 PULLUP_N_BLEED_5 PULLUP_P 5.13203e-17
C536 TERM_OR_N_B HS_N 8.49624e-17
C537 TERM_N_R HS_P 1.73336e-16
C538 FS_P_OUT HS_P_12 1.09233e-16
C539 TERM_GATE_N_BLEED_2 PULLUP_P 9.19551e-17
C540 FS_N_WELL HS_N 5.18412e-15
C541 FS_P_BLEED_2 HS_P 3.47206e-17
C542 HS_N_1 TERM_N_R 1.25932e-16
C543 PULLUP_N_BLEED_1 DIV_ENABLE 3.56355e-17
C544 TERM_OR_P_B PULLUP_P_OUT 1.99512e-16
C545 FS_P_BLEED_2 HS_N_1 3.47206e-17
C546 HS_N_5 TERM_GATE_P_BLEED_0 3.33636e-19
C547 TERM_GATE_P_BLEED_0 HS_P_3 2.46413e-17
C548 FS_P_OUT HS_N_6 4.33306e-16
C549 TERM_P_R FS_HIGH_N 7.19183e-18
C550 PAD_P HS_P_13 1.35247e-15
C551 FS_P_WELL HS_P_12 1.31511e-17
C552 TERM_GATE_N TERM_GATE_N_BLEED_0 2.02705e-15
C553 HS_N_0 PULLUP_P_BLEED_5 5.2922e-17
C554 HS_N_7 PULLUP_P_BLEED_0 5.67482e-19
C555 HS_N PULLUP_P_GATE 1.66091e-16
C556 HS_N_5 FS_P_GATE 1.02138e-15
C557 DIV_LOW_N HS_P 6.1779e-17
C558 VDD HS_P_3 6.15154e-15
C559 HS_P_4 HS_P_1 3.20664e-17
C560 HS_N_5 VDD 6.46437e-15
C561 DIV_ENABLE FS_HIGH_P 4.86815e-15
C562 DIV_LOW_N HS_N_1 6.92554e-17
C563 TERM_GATE_N_BLEED_1 PULLUP_P 5.46167e-17
C564 HS_N_6 FS_P_WELL 1.94094e-15
C565 PULLUP_N_OUT PULLUP_N_WELL 3.25337e-14
C566 HS_P_5 HS_P_3 3.19202e-17
C567 FS_N_GATE DIV_ENABLE 4.50932e-18
C568 HS_N_11 HS_N_0 3.96402e-17
C569 HS_N_0 DIV_P 3.38809e-17
C570 HS_N_5 HS_P_5 1.02947e-16
C571 HS_N_9 HS_P_6 5.49271e-17
C572 FS_N_CONTROL_S PULLUP_N_OUT 1.04601e-16
C573 HS_N_10 TERM_P_R 6.03432e-17
C574 HS_N_0 FS_LOW_P 8.51626e-17
C575 TERM_ENABLE PULLUP_P 9.05208e-17
C576 TERM_P_R TERM_OR_P_S 2.01371e-15
C577 PULLUP_N_CONTROL_S HS_PBIAS 9.33173e-17
C578 TERM_GATE_P_BLEED_0 TERM_GATE_P 4.84915e-15
C579 FS_P_OUT HS_N_8 4.33669e-16
C580 HS_N_7 TERM_GATE_P_BLEED_0 5.67482e-19
C581 PULLUP_N_BLEED_0 PULLUP_N_CONTROL_S 5.53351e-18
C582 PAD_P HS_P_8 1.09993e-15
C583 HS_N_7 FS_P_GATE 1.02868e-15
C584 VDD TERM_GATE_P 7.09963e-15
C585 FS_N_BLEED_4 PULLUP_P 1.01235e-16
C586 HS_N_7 VDD 6.97907e-15
C587 HS_P_4 HS_P_3 3.36448e-14
C588 HS_N_5 HS_P_4 1.33069e-16
C589 PULLUP_N_WELL PULLDOWN_P 4.31987e-16
C590 HS_N_8 FS_P_WELL 1.96551e-15
C591 HS_P_5 TERM_GATE_P 1.55986e-16
C592 HS_N_7 HS_P_5 3.48887e-17
C593 TERM_ENABLE FS_P_BLEED_1 1.10378e-16
C594 HS_N_0 DIV_LOW_P 5.84916e-18
C595 VCM_LOW_OK PULLDOWN_P_R 6.55349e-17
C596 FS_P_BLEED_4 PULLUP_P_GATE 4.70063e-19
C597 TERM_GATE_N_BLEED_0 TERM_N_R 1.69431e-16
C598 FS_N_CONTROL_S PULLDOWN_P 9.19309e-17
C599 PULLUP_N_BLEED_4 PULLUP_P 2.0817e-19
C600 HS_N_13 HS_N_0 7.74685e-17
C601 HS_N_12 TERM_P_R 5.97047e-17
C602 HS_P_7 HS_P_12 1.13762e-16
C603 PULLDOWN_N_R PAD_P 1.40429e-15
C604 FS_LOW_N PULLUP_P 6.42575e-17
C605 PULLUP_N_BLEED_2 VDD 3.14506e-19
C606 HS_P_6 HS_P_11 6.71316e-17
C607 PULLUP_N_OUT HS_PBIAS 8.01866e-16
C608 HS_N DIV_ENABLE 5.80205e-17
C609 DIV_P BYPASS_ENABLE 5.9579e-17
C610 TERM_GATE_P_BLEED_2 TERM_GATE_P 4.03441e-16
C611 TERM_P_R FS_N_OUT 3.45179e-16
C612 FS_P_OUT TERM_VCM 3.86377e-16
C613 PAD_P HS_P_10 1.26307e-15
C614 VCM_LOW_OK HS_N 4.12239e-17
C615 TERM_GATE_N VDD 5.37342e-15
C616 HS_P_4 TERM_GATE_P 1.56269e-16
C617 TERM_ENABLE HS_P_0 3.03728e-17
C618 FS_N_BLEED_6 PULLDOWN_N_R 4.81135e-17
C619 TERM_VCM FS_P_WELL 1.5778e-15
C620 FS_HIGH_N FS_N_OUT 2.03025e-17
C621 HS_P_7 HS_P_2 6.18445e-17
C622 DIV_P RX_P 1.39534e-15
C623 HS_N_3 HS_N_0 7.84243e-17
C624 TERM_OR_N_S PULLDOWN_N_R 1.27566e-16
C625 HS_N_2 TERM_P_R 5.93974e-17
C626 HS_N_10 HS_N_12 1.1003e-17
C627 HS_P_0 TERM_OR_P_NS 7.62118e-17
C628 PULLUP_P_BLEED_1 PULLDOWN_P_R 1.41333e-17
C629 HS_PBIAS PULLDOWN_P 4.38779e-16
C630 TERM_P_R PULLUP_P_CONTROL_S 4.71855e-17
C631 DIV_LOW_P BYPASS_ENABLE 6.21526e-19
C632 HS_N_8 HS_P_7 9.18219e-17
C633 HS_N_10 FS_N_OUT 5.27536e-18
C634 PULLUP_N_BLEED_0 PULLDOWN_P 1.05682e-18
C635 PULLUP_N_CONTROL_S PULLUP_N_OUT 6.5761e-19
C636 PAD_P DIV_P 2.52941e-15
C637 HS_N_11 PAD_P 3.88485e-16
C638 DIV_N FS_P_GATE 9.34087e-17
C639 DIV_N VDD 4.45448e-16
C640 FS_N_BLEED_6 PULLUP_N_GATE 5.48293e-18
C641 PULLUP_P_BLEED_3 PULLUP_P_GATE 1.89537e-16
C642 HS_N_9 HS_PBIAS 3.54149e-15
C643 TERM_GATE_P_BLEED_0 TERM_N_R 1.44632e-16
C644 DIV_N HS_P_5 1.20294e-17
C645 HS_N_0 HS_P_3 2.68576e-17
C646 TERM_OR_N_S PULLUP_P_BLEED_5 2.57363e-18
C647 FS_P_GATE TERM_N_R 7.54625e-16
C648 HS_N_5 HS_N_0 3.91118e-17
C649 HS_N_10 HS_N_2 4.41474e-17
C650 TERM_OR_N_B PULLDOWN_N_R 8.06407e-17
C651 HS_N_4 TERM_P_R 5.89263e-17
C652 VDD TERM_N_R 6.61679e-15
C653 HS_P_0 PAD_N 3.83145e-16
C654 FS_P_BLEED_2 FS_P_GATE 2.00085e-16
C655 HS_N_10 PULLUP_P_CONTROL_S 3.48887e-17
C656 PULLDOWN_N_R FS_N_WELL 2.2767e-15
C657 HS_PBIAS FS_P_CONTROL_S 4.86088e-17
C658 FS_N_BLEED_6 FS_LOW_P 1.81426e-16
C659 FS_P_BLEED_2 VDD 4.46753e-16
C660 HS_N_1 PULLUP_P 5.06175e-17
C661 HS_N_12 FS_N_OUT 5.27536e-18
C662 TERM_VCM HS_P_7 9.61503e-17
C663 PULLUP_N_CONTROL_S PULLDOWN_P 3.06486e-17
C664 FS_N_BLEED_2 PULLUP_N_WELL 6.74983e-19
C665 HS_P_9 PULLDOWN_P_R 7.46551e-17
C666 HS_N_11 TERM_OR_N_S 6.33501e-17
C667 HS_N_13 PAD_P 8.1518e-17
C668 PULLDOWN_N_R PULLUP_P_GATE 2.22433e-16
C669 DIV_LOW_N VDD 1.17561e-18
C670 TERM_OR_N_S FS_LOW_P 8.19409e-17
C671 TERM_P_R HS_P_12 1.10662e-16
C672 TERM_GATE_P_BLEED_2 TERM_N_R 8.43202e-16
C673 HS_N_0 TERM_GATE_P 1.10833e-16
C674 HS_P FS_P_BLEED_1 6.1779e-17
C675 HS_N_7 HS_N_0 7.11334e-17
C676 VCM_LOW_OK HS_P_13 3.48887e-17
C677 HS_N_6 TERM_P_R 5.89263e-17
C678 HS_N_12 HS_N_2 3.55427e-17
C679 HS_N_10 HS_N_4 2.82661e-19
C680 HS_PBIAS HS_P_11 9.38284e-15
C681 HS_N_1 FS_P_BLEED_1 6.1779e-17
C682 TERM_N_R HS_P_4 5.72216e-17
C683 HS_N_12 PULLUP_P_CONTROL_S 3.48887e-17
C684 HS_N HS_P_9 1.21888e-16
C685 TERM_OR_P_B PULLDOWN_P_R 1.79486e-16
C686 HS_N_2 FS_N_OUT 6.16744e-17
C687 FS_P_OUT TERM_ENABLE 5.4337e-16
C688 PULLUP_P_BLEED_5 PULLUP_P_GATE 1.47587e-16
C689 HS_N_13 TERM_OR_N_S 6.33501e-17
C690 HS_N_3 PAD_P 9.10423e-17
C691 TERM_P_R HS_P_2 8.49117e-17
C692 HS_N_11 TERM_OR_N_B 2.97776e-17
C693 PAD_P HS_P_1 1.23396e-15
C694 FS_N_BLEED_1 PULLUP_N_WELL 6.74983e-19
C695 PULLUP_N_OUT PULLDOWN_P 7.84673e-17
C696 FS_N_OUT PULLUP_P_CONTROL_S 6.16744e-17
C697 FS_N_BLEED_3 PULLUP_P 4.81895e-17
C698 HS_N_11 FS_N_WELL 1.99681e-17
C699 HS_N_10 HS_P_12 7.70877e-17
C700 HS_PBIAS PULLUP_P_BLEED_4 4.82815e-17
C701 HS_P HS_P_0 1.77665e-14
C702 PULLUP_N_OUT PULLUP_P_BLEED_2 4.04393e-19
C703 FS_N_WELL FS_LOW_P 1.62693e-15
C704 TERM_ENABLE FS_P_WELL 2.59589e-15
C705 HS_N_1 HS_P_0 4.11318e-17
C706 HS_PBIAS FS_N_BLEED_2 9.92609e-17
C707 HS_N_11 PULLUP_P_GATE 7.36343e-17
C708 HS_N TERM_OR_P_B 1.31105e-16
C709 HS_N_12 HS_N_4 6.21526e-19
C710 HS_N_10 HS_N_6 1.52593e-19
C711 PAD_N RX_N 8.2012e-15
C712 TERM_GATE_N HS_N_0 5.23782e-17
C713 VCM_LOW_OK PULLUP_P_BLEED_3 1.56024e-16
C714 VCM_LOW_OK HS_P_8 3.48887e-17
C715 HS_N_8 TERM_P_R 1.00539e-16
C716 FS_LOW_P PULLUP_P_GATE 6.87755e-17
C717 PULLUP_N_OUT HS_N_9 1.49245e-17
C718 HS_N_2 PULLUP_P_CONTROL_S 3.48887e-17
C719 PULLDOWN_N_R DIV_ENABLE 4.45496e-17
C720 PULLUP_P_WELL TERM_P_R 3.22671e-16
C721 PULLDOWN_N PULLDOWN_P 2.82816e-15
C722 PAD_P HS_P_3 1.68578e-15
C723 HS_PBIAS DIFF_ENABLE 1.71385e-16
C724 TERM_P_R FS_N_BLEED_5 1.11411e-16
C725 HS_N_3 TERM_OR_N_S 6.48797e-17
C726 HS_N_13 TERM_OR_N_B 2.92151e-17
C727 HS_N_5 PAD_P 3.42428e-16
C728 HS_N_12 HS_P_12 8.27225e-17
C729 HS_N_13 FS_N_WELL 2.09732e-17
C730 PULLDOWN_N_R VCM_LOW_OK 9.09167e-17
C731 VCM_LOW_OK FS_P_BLEED_0 1.46148e-17
C732 FS_P_OUT PAD_N 1.89403e-15
C733 HS_PBIAS FS_N_BLEED_1 7.79762e-17
C734 HS_N_0 PULLUP_P_BLEED_6 2.49209e-17
C735 HS_N_13 PULLUP_P_GATE 7.27112e-17
C736 DIV_N HS_N_0 4.09716e-17
C737 FS_N_OUT HS_P_12 1.23349e-16
C738 HS_N_2 HS_N_4 2.0615e-18
C739 HS_N_12 HS_N_6 2.82661e-19
C740 TERM_VCM TERM_P_R 1.97862e-13
C741 VCM_LOW_OK HS_P_10 9.05211e-17
C742 HS_N_4 PULLUP_P_CONTROL_S 3.48887e-17
C743 PULLUP_P_BLEED_0 PULLUP_P 8.52781e-16
C744 DIV_ENABLE PULLUP_P_BLEED_5 2.67272e-19
C745 PULLUP_P_BLEED_1 PULLUP_P_BLEED_3 1.09742e-16
C746 PULLUP_N_OUT HS_P_11 8.82385e-17
C747 PULLUP_N_GATE DIV_ENABLE 6.06007e-19
C748 HS_N_10 PULLUP_P_WELL 2.16705e-16
C749 HS_PBIAS PULLUP_P_OUT 5.0651e-16
C750 TERM_ENABLE HS_P_7 2.40376e-17
C751 HS_N_3 TERM_OR_N_B 2.84614e-17
C752 HS_N_5 TERM_OR_N_S 6.59331e-17
C753 HS_N_7 PAD_P 3.8292e-17
C754 HS_N_0 TERM_N_R 1.21272e-16
C755 HS_P_9 HS_P_13 4.87706e-17
C756 DIV_ENABLE DIV_P 4.7677e-15
C757 HS_N_2 HS_P_12 6.57781e-17
C758 HS_N_0 FS_P_BLEED_2 3.47206e-17
C759 HS_N_11 DIV_ENABLE 3.16132e-17
C760 HS_P_7 TERM_OR_P_NS 2.84614e-17
C761 PULLDOWN_N_R PULLUP_P_BLEED_1 1.94556e-18
C762 DIV_ENABLE FS_LOW_P 1.08576e-16
C763 HS_N_3 PULLUP_P_GATE 7.21128e-17
C764 PULLUP_N_OUT PULLUP_P_BLEED_4 5.47208e-17
C765 HS_N_10 TERM_VCM 1.20188e-16
C766 HS_N_2 HS_N_6 6.21526e-19
C767 HS_N_12 HS_N_8 1.52593e-19
C768 DIV_LOW_N HS_N_0 6.94888e-17
C769 PULLUP_N_OUT TERM_GATE_P_BLEED_1 5.31754e-17
C770 HS_N_11 VCM_LOW_OK 3.48887e-17
C771 VCM_LOW_OK DIV_P 8.92332e-18
C772 TERM_VCM TERM_OR_P_S 5.96309e-17
C773 HS_N_6 PULLUP_P_CONTROL_S 3.48887e-17
C774 HS_N_9 FS_P_CONTROL_S 3.24151e-17
C775 VCM_LOW_OK FS_LOW_P 2.2718e-16
C776 PULLUP_N_OUT FS_N_BLEED_2 7.24459e-19
C777 VDD PULLUP_P 2.44148e-15
C778 HS_N_12 PULLUP_P_WELL 1.93659e-16
C779 TERM_OR_P_B HS_P_13 1.03886e-16
C780 DIV_N BYPASS_ENABLE 9.43608e-17
C781 HS_N_5 TERM_OR_N_B 2.84614e-17
C782 HS_N_7 TERM_OR_N_S 6.82648e-17
C783 HS_N_2 HS_P_2 6.70368e-17
C784 FS_P_OUT HS_P 6.85311e-16
C785 FS_P_OUT HS_N_1 4.46857e-16
C786 HS_N_4 HS_P_12 7.18129e-17
C787 PULLUP_P_WELL FS_N_OUT 1.44465e-16
C788 HS_P_9 HS_P_8 3.03927e-14
C789 DIV_ENABLE DIV_LOW_P 2.67093e-15
C790 HS_N_13 DIV_ENABLE 3.08895e-17
C791 HS_P_7 PAD_N 3.61296e-16
C792 HS_P FS_P_WELL 2.05815e-15
C793 DIV_N RX_P 7.26653e-16
C794 FS_P_GATE FS_P_BLEED_1 1.63747e-16
C795 TERM_N_R BYPASS_ENABLE 4.44394e-18
C796 TERM_P_R PULLUP_N_BLEED_5 9.36835e-19
C797 HS_N_9 HS_P_11 3.10308e-17
C798 HS_N_1 FS_P_WELL 2.0924e-15
C799 HS_N_5 PULLUP_P_GATE 7.37624e-17
C800 PULLUP_P_BLEED_4 PULLDOWN_P 2.16295e-19
C801 HS_N_12 TERM_VCM 1.20188e-16
C802 HS_N_2 HS_N_8 2.82661e-19
C803 FS_P_BLEED_2 BYPASS_ENABLE 7.65665e-18
C804 HS_N_4 HS_N_6 7.07539e-17
C805 VDD FS_P_BLEED_1 6.21292e-16
C806 HS_N_13 VCM_LOW_OK 3.48887e-17
C807 HS_N_8 PULLUP_P_CONTROL_S 3.48887e-17
C808 FS_N_BLEED_2 PULLDOWN_P 7.40722e-17
C809 PULLDOWN_N_R HS_P_9 4.1634e-15
C810 PULLUP_P_BLEED_2 PULLUP_P_BLEED_4 8.54567e-18
C811 HS_N_2 PULLUP_P_WELL 1.77836e-16
C812 HS_PBIAS FS_P_BLEED_5 9.92609e-17
C813 HS_P_6 PULLDOWN_P_R 2.40376e-17
C814 TERM_OR_P_B HS_P_8 1.00574e-16
C815 DIV_LOW_N BYPASS_ENABLE 1.05682e-18
C816 HS_N_4 HS_P_2 3.76364e-18
C817 TERM_VCM FS_N_OUT 4.77098e-16
C818 PULLUP_N_WELL PULLUP_N_BLEED_1 8.20771e-17
C819 HS_N_7 TERM_OR_N_B 2.84614e-17
C820 TERM_GATE_N TERM_OR_N_S 1.21173e-17
C821 DIV_N PAD_P 4.53665e-16
C822 PULLUP_P_WELL PULLUP_P_CONTROL_S 3.85921e-16
C823 PULLUP_N_OUT PULLUP_P_OUT 1.73969e-16
C824 TERM_GATE_P_BLEED_0 HS_P_0 5.91203e-18
C825 HS_N_9 PULLUP_P_BLEED_4 3.48887e-17
C826 TERM_P_R TERM_GATE_N_BLEED_1 4.76598e-17
C827 HS_P_9 HS_P_10 8.86842e-18
C828 HS_N_6 HS_P_12 6.57781e-17
C829 HS_N_3 DIV_ENABLE 3.08895e-17
C830 PULLDOWN_N DIFF_ENABLE 1.2241e-16
C831 DIFF_ENABLE PULLDOWN_P 1.10108e-16
C832 VDD HS_P_0 3.96008e-15
C833 PULLUP_N_WELL FS_HIGH_P 2.13545e-16
C834 HS_N_7 PULLUP_P_GATE 7.49248e-17
C835 PULLDOWN_N_R TERM_OR_P_B 1.69541e-16
C836 HS_N_2 TERM_VCM 1.23237e-16
C837 TERM_N_R PAD_P 1.88678e-16
C838 HS_N_4 HS_N_8 4.06164e-17
C839 HS_N_10 TERM_GATE_N_BLEED_2 5.26957e-17
C840 VCM_LOW_OK HS_P_1 3.48887e-17
C841 HS_N_3 VCM_LOW_OK 3.48887e-17
C842 TERM_ENABLE TERM_P_R 5.42615e-16
C843 HS_P_6 HS_N 5.26502e-16
C844 HS_P_12 HS_P_2 2.0615e-18
C845 HS_P_5 HS_P_0 2.97357e-18
C846 TERM_VCM PULLUP_P_CONTROL_S 3.42463e-17
C847 HS_PBIAS FS_P_BLEED_6 8.85647e-17
C848 HS_N_4 PULLUP_P_WELL 1.83709e-16
C849 TERM_OR_P_B HS_P_10 9.64357e-17
C850 TERM_ENABLE FS_HIGH_N 1.51257e-17
C851 TERM_OR_N_S PULLUP_P_BLEED_6 2.57363e-18
C852 HS_N_6 HS_P_2 3.08895e-17
C853 TERM_P_R TERM_OR_P_NS 2.25891e-16
C854 DIV_N TERM_OR_N_S 4.31015e-19
C855 HS_P_7 HS_P 5.33033e-16
C856 FS_N_CONTROL_S FS_N_GATE 3.06738e-15
C857 TERM_P_R FS_N_BLEED_4 4.58761e-17
C858 TERM_GATE_N TERM_OR_N_B 2.35344e-15
C859 HS_N_10 TERM_GATE_N_BLEED_1 3.48887e-17
C860 HS_N_8 HS_P_12 6.33501e-17
C861 FS_N_BLEED_6 TERM_N_R 6.10527e-17
C862 HS_N_5 DIV_ENABLE 3.08895e-17
C863 FS_HIGH_N FS_N_BLEED_4 1.52593e-19
C864 HS_P_9 FS_LOW_P 5.65665e-17
C865 HS_PBIAS PULLUP_N_BLEED_1 4.82815e-17
C866 HS_P_0 HS_P_4 2.18985e-18
C867 TERM_P_R PULLUP_N_BLEED_4 9.36835e-19
C868 TERM_OR_N_S TERM_N_R 1.3199e-16
C869 HS_N_4 TERM_VCM 1.2576e-16
C870 VCM_LOW_OK HS_P_3 9.10393e-17
C871 HS_N_6 HS_N_8 4.94565e-17
C872 HS_N_10 TERM_ENABLE 4.83462e-17
C873 HS_N_12 TERM_GATE_N_BLEED_2 5.26312e-17
C874 FS_LOW_N TERM_P_R 1.05074e-16
C875 TERM_ENABLE TERM_OR_P_S 2.30444e-16
C876 HS_N_5 VCM_LOW_OK 3.5346e-17
C877 PULLUP_N_BLEED_0 PULLUP_N_BLEED_1 4.9716e-15
C878 HS_N_9 PULLUP_P_OUT 2.40376e-17
C879 FS_LOW_N FS_HIGH_N 4.57398e-17
C880 TERM_GATE_N_BLEED_2 FS_N_OUT 6.40782e-17
C881 HS_PBIAS FS_HIGH_P 3.86543e-17
C882 HS_N_6 PULLUP_P_WELL 1.84121e-16
C883 HS_N_8 HS_P_2 2.40376e-17
C884 PULLUP_N_WELL HS_N 7.15674e-16
C885 TERM_OR_P_B DIV_P 2.22993e-17
C886 HS_N_11 TERM_OR_P_B 7.338e-17
C887 HS_N_12 TERM_GATE_N_BLEED_1 3.48887e-17
C888 TERM_OR_P_S TERM_OR_P_NS 7.35739e-18
C889 HS_PBIAS FS_N_GATE 2.74154e-15
C890 PULLUP_N_OUT FS_P_BLEED_5 7.24459e-19
C891 DIV_ENABLE TERM_GATE_P 4.32213e-18
C892 TERM_OR_P_B FS_LOW_P 1.1369e-15
C893 TERM_VCM HS_P_12 1.07001e-16
C894 HS_N_7 DIV_ENABLE 3.08895e-17
C895 HS_N_0 PULLUP_P 5.06175e-17
C896 FS_N_CONTROL_S HS_N 1.18717e-16
C897 PULLUP_P_BLEED_6 PULLUP_P_GATE 3.36504e-15
C898 TERM_GATE_N_BLEED_1 FS_N_OUT 6.16744e-17
C899 DIV_N PULLUP_P_GATE 1.34827e-18
C900 TERM_OR_N_B TERM_N_R 5.99904e-15
C901 HS_N_2 TERM_GATE_N_BLEED_2 5.2499e-17
C902 HS_N_6 TERM_VCM 1.30158e-16
C903 HS_N_12 TERM_ENABLE 4.825e-17
C904 HS_N_10 FS_LOW_N 4.61521e-17
C905 HS_N_7 VCM_LOW_OK 3.56562e-17
C906 VCM_LOW_OK TERM_GATE_P 2.01883e-16
C907 PULLUP_N_CONTROL_S PULLUP_N_BLEED_1 5.14019e-19
C908 FS_N_WELL TERM_N_R 1.69175e-15
C909 PULLUP_N_BLEED_2 DIV_ENABLE 2.67272e-19
C910 HS_PBIAS PULLDOWN_P_R 5.05936e-16
C911 HS_N_8 PULLUP_P_WELL 1.98765e-16
C912 TERM_ENABLE FS_N_OUT 5.47642e-16
C913 TERM_VCM HS_P_2 9.61503e-17
C914 HS_P_11 PULLUP_P_OUT 5.51888e-17
C915 HS_N_0 FS_P_BLEED_1 6.1779e-17
C916 TERM_N_R PULLUP_P_GATE 2.08331e-16
C917 HS_N_13 TERM_OR_P_B 7.27112e-17
C918 HS_N_10 PAD_N 1.35483e-15
C919 FS_P_OUT FS_P_GATE 1.35377e-13
C920 HS_P_6 HS_P_13 1.59595e-16
C921 HS_N_2 TERM_GATE_N_BLEED_1 3.48887e-17
C922 FS_P_OUT VDD 1.10127e-14
C923 PULLUP_N_OUT FS_P_BLEED_6 5.92219e-17
C924 HS_P_9 HS_P_1 3.49441e-17
C925 FS_P_BLEED_2 PULLUP_P_GATE 4.48462e-18
C926 FS_P_GATE FS_P_WELL 2.63587e-13
C927 TERM_GATE_N DIV_ENABLE 1.28396e-16
C928 VDD FS_P_WELL 1.30881e-13
C929 FS_P_OUT HS_P_5 5.46167e-17
C930 FS_N_BLEED_2 FS_N_BLEED_1 3.07801e-15
C931 HS_PBIAS HS_N 3.96706e-16
C932 HS_N_2 TERM_ENABLE 4.80752e-17
C933 HS_N_4 TERM_GATE_N_BLEED_2 5.2499e-17
C934 HS_N_8 TERM_VCM 1.76585e-16
C935 HS_N_12 FS_LOW_N 4.59909e-17
C936 TERM_P_R HS_P 1.66901e-16
C937 TERM_GATE_N VCM_LOW_OK 5.30337e-18
C938 TERM_ENABLE PULLUP_P_CONTROL_S 5.71052e-17
C939 PULLUP_N_OUT PULLUP_N_BLEED_1 3.04895e-18
C940 HS_N_0 HS_P_0 4.06066e-17
C941 TERM_GATE_P_BLEED_1 PULLUP_P_OUT 1.4929e-16
C942 HS_N_1 TERM_P_R 1.02275e-16
C943 HS_N_9 FS_P_BLEED_5 6.29519e-17
C944 TERM_VCM PULLUP_P_WELL 3.82843e-16
C945 FS_LOW_N FS_N_OUT 3.14208e-16
C946 TERM_VCM FS_N_BLEED_5 1.37591e-16
C947 HS_N_3 TERM_OR_P_B 7.21128e-17
C948 FS_HIGH_N HS_P 3.74305e-17
C949 HS_N_12 PAD_N 1.21768e-15
C950 TERM_OR_P_B HS_P_1 8.19117e-17
C951 HS_P_6 HS_P_8 2.0615e-18
C952 HS_N_4 TERM_GATE_N_BLEED_1 3.48887e-17
C953 HS_P_9 HS_P_3 4.19373e-17
C954 DIV_N DIV_ENABLE 3.30015e-14
C955 FS_N_OUT PAD_N 4.10443e-15
C956 PULLUP_N_OUT FS_N_GATE 1.11467e-15
C957 HS_N_4 TERM_ENABLE 4.80752e-17
C958 HS_N_6 TERM_GATE_N_BLEED_2 5.2499e-17
C959 HS_N_2 FS_LOW_N 8.74721e-17
C960 DIV_N VCM_LOW_OK 4.31015e-19
C961 HS_N_10 HS_P 2.07358e-16
C962 PULLDOWN_N_R HS_P_6 2.41417e-17
C963 PULLUP_N_BLEED_1 PULLDOWN_P 4.15346e-17
C964 HS_N_10 HS_N_1 1.24994e-13
C965 TERM_N_R DIV_ENABLE 1.69354e-16
C966 TERM_GATE_P_BLEED_0 HS_P_7 2.40376e-17
C967 HS_N_9 FS_P_BLEED_6 6.1779e-17
C968 TERM_OR_P_B HS_P_3 1.02378e-16
C969 FS_P_BLEED_2 DIV_ENABLE 1.37454e-17
C970 HS_PBIAS FS_P_BLEED_4 8.38415e-17
C971 HS_N_5 TERM_OR_P_B 7.21128e-17
C972 HS_N_4 TERM_OR_P_NS 1.96068e-18
C973 PULLUP_N_OUT PULLDOWN_P_R 6.25611e-17
C974 HS_N_2 PAD_N 1.16258e-15
C975 PULLUP_N PULLUP_N_WELL 1.16079e-16
C976 HS_P_6 HS_P_10 7.64563e-17
C977 HS_N_6 TERM_GATE_N_BLEED_1 3.48887e-17
C978 VDD HS_P_7 4.96755e-15
C979 TERM_N_R VCM_LOW_OK 1.46988e-16
C980 TERM_ENABLE HS_P_12 2.40376e-17
C981 HS_P_9 TERM_GATE_P 2.20515e-16
C982 FS_HIGH_N FS_N_BLEED_3 2.0817e-19
C983 DIV_LOW_N DIV_ENABLE 8.13107e-15
C984 FS_P_BLEED_2 VCM_LOW_OK 3.80972e-17
C985 FS_N_BLEED_6 PULLUP_P 5.44487e-17
C986 FS_N_GATE PULLDOWN_P 1.32493e-15
C987 HS_P_7 HS_P_5 3.0785e-17
C988 HS_P_0 RX_P 2.06839e-20
C989 HS_N_4 FS_LOW_N 4.57398e-17
C990 HS_N_8 TERM_GATE_N_BLEED_2 5.2499e-17
C991 HS_N_6 TERM_ENABLE 8.99634e-17
C992 HS_N_12 HS_P 7.85887e-16
C993 TERM_GATE_N_BLEED_0 TERM_P_R 1.06275e-16
C994 HS_N_0 RX_N 3.048e-18
C995 HS_P_12 TERM_OR_P_NS 3.93125e-17
C996 TERM_OR_N_S PULLUP_P 1.46572e-16
C997 HS_N_12 HS_N_1 7.58432e-17
C998 PULLUP_N_OUT HS_N 1.08552e-16
C999 HS_N_9 FS_HIGH_P 1.12441e-17
C1000 HS_PBIAS HS_P_13 2.35174e-15
C1001 HS_N_7 TERM_OR_P_B 7.21128e-17
C1002 FS_N_OUT HS_P 7.63245e-16
C1003 HS_N_6 TERM_OR_P_NS 3.50851e-18
C1004 TERM_ENABLE HS_P_2 6.39171e-17
C1005 HS_N_4 PAD_N 1.29614e-15
C1006 FS_N_BLEED_0 FS_HIGH_N 9.64337e-18
C1007 PULLDOWN_P PULLDOWN_P_R 5.93443e-16
C1008 TERM_OR_P_B TERM_GATE_P 1.29405e-14
C1009 HS_P_6 DIV_P 3.38809e-17
C1010 PULLDOWN_N_R PULLUP_N_WELL 3.20503e-16
C1011 HS_N_8 TERM_GATE_N_BLEED_1 3.48887e-17
C1012 HS_N_9 FS_N_GATE 2.25616e-18
C1013 HS_N_11 HS_P_6 5.93224e-17
C1014 HS_P_7 HS_P_4 6.06671e-17
C1015 HS_P_6 FS_LOW_P 4.566e-17
C1016 PAD_P HS_P_0 1.64028e-15
C1017 FS_P_CONTROL_S FS_HIGH_P 4.75375e-16
C1018 FS_N_CONTROL_S PULLDOWN_N_R 9.19309e-17
C1019 HS_P_2 TERM_OR_P_NS 2.84614e-17
C1020 HS_N_0 FS_P_OUT 5.60895e-16
C1021 HS_PBIAS PULLUP_N 2.68187e-17
C1022 HS_N_6 FS_LOW_N 4.57398e-17
C1023 HS_N_8 TERM_ENABLE 1.0575e-16
C1024 TERM_VCM TERM_GATE_N_BLEED_2 1.50283e-17
C1025 HS_N_2 HS_P 8.52929e-16
C1026 HS_P_12 PAD_N 2.23241e-16
C1027 HS_N_9 PULLDOWN_P_R 2.40376e-17
C1028 TERM_OR_N_B PULLUP_P 1.35721e-16
C1029 PULLUP_N_BLEED_0 PULLUP_N 7.9203e-16
C1030 HS_P PULLUP_P_CONTROL_S 3.48887e-17
C1031 HS_N_2 HS_N_1 1.10911e-16
C1032 HS_N_0 FS_P_WELL 2.67879e-15
C1033 HS_PBIAS HS_P_8 1.54227e-15
C1034 TERM_ENABLE PULLUP_P_WELL 2.32441e-15
C1035 TERM_ENABLE FS_N_BLEED_5 1.1535e-16
C1036 FS_N_WELL PULLUP_P 1.97293e-15
C1037 HS_N_1 PULLUP_P_CONTROL_S 3.48887e-17
C1038 HS_N_8 TERM_OR_P_NS 7.03846e-18
C1039 BYPASS_ENABLE RX_N 7.14161e-15
C1040 HS_N_6 PAD_N 1.1595e-15
C1041 PULLUP_N_GATE PULLUP_N_WELL 3.63451e-14
C1042 TERM_VCM TERM_GATE_N_BLEED_1 4.28264e-17
C1043 HS_N_13 HS_P_6 5.88824e-17
C1044 PULLUP_P PULLUP_P_GATE 3.89342e-15
C1045 FS_N_BLEED_5 FS_N_BLEED_4 7.71303e-15
C1046 HS_N_9 HS_N 5.92574e-15
C1047 HS_P_2 PAD_N 2.43754e-15
C1048 HS_PBIAS PULLDOWN_N_R 7.7848e-16
C1049 RX_P RX_N 7.49731e-15
C1050 TERM_GATE_P_BLEED_0 TERM_P_R 2.57363e-18
C1051 HS_PBIAS FS_P_BLEED_0 8.85647e-17
C1052 HS_N_8 FS_LOW_N 4.57398e-17
C1053 TERM_VCM TERM_ENABLE 5.22073e-16
C1054 HS_N_4 HS_P 3.25189e-16
C1055 PULLUP_N_WELL FS_LOW_P 2.25874e-16
C1056 FS_HIGH_P PULLUP_P_BLEED_4 1.64407e-16
C1057 FS_P_GATE TERM_P_R 7.60354e-16
C1058 HS_N_4 HS_N_1 4.30471e-17
C1059 PULLUP_N_BLEED_0 PULLDOWN_N_R 6.21526e-19
C1060 PULLUP_N_CONTROL_S PULLUP_N 1.77933e-15
C1061 VDD TERM_P_R 6.10049e-15
C1062 HS_P_11 PULLDOWN_P_R 7.46551e-17
C1063 HS_N FS_P_CONTROL_S 4.34218e-17
C1064 FS_N_CONTROL_S FS_LOW_P 4.63397e-17
C1065 FS_N_BLEED_2 FS_HIGH_P 4.04393e-19
C1066 FS_LOW_N FS_N_BLEED_5 2.0817e-19
C1067 TERM_VCM FS_N_BLEED_4 2.04122e-17
C1068 HS_PBIAS HS_P_10 8.55407e-15
C1069 TERM_VCM TERM_OR_P_NS 1.29841e-18
C1070 HS_N_8 PAD_N 1.07245e-15
C1071 DIFF_ENABLE PULLUP_N_BLEED_1 1.12958e-18
C1072 FS_P_BLEED_1 PULLUP_P_GATE 9.16675e-20
C1073 DIV_N TERM_OR_P_B 1.34827e-18
C1074 HS_P_6 HS_P_1 6.27077e-17
C1075 TERM_P_R HS_P_5 8.37422e-17
C1076 VDD FS_HIGH_N 5.856e-17
C1077 HS_N_3 HS_P_6 5.82839e-17
C1078 FS_N_BLEED_2 FS_N_GATE 1.79465e-16
C1079 PULLUP_N_OUT HS_P_13 2.8681e-17
C1080 PAD_P RX_N 3.7917e-16
C1081 FS_P_WELL BYPASS_ENABLE 5.75902e-17
C1082 FS_P_BLEED_3 FS_P_BLEED_5 1.28312e-16
C1083 HS_P HS_P_12 3.63983e-15
C1084 PULLUP_P_OUT FS_P_BLEED_6 5.12704e-17
C1085 FS_P_OUT RX_P 1.23787e-17
C1086 HS_PBIAS PULLUP_P_BLEED_5 7.92848e-17
C1087 DIFF_ENABLE FS_HIGH_P 1.99196e-16
C1088 TERM_N_R TERM_OR_P_B 1.12426e-15
C1089 HS_N_1 HS_P_12 6.33501e-17
C1090 PULLUP_P_BLEED_4 PULLDOWN_P_R 5.46167e-17
C1091 HS_PBIAS PULLUP_N_GATE 1.6144e-16
C1092 HS_N HS_P_11 6.68797e-16
C1093 HS_N_6 HS_P 1.04391e-15
C1094 TERM_GATE_P_BLEED_2 TERM_P_R 6.55126e-17
C1095 TERM_GATE_P_BLEED_1 PULLDOWN_P_R 1.41333e-17
C1096 TERM_VCM FS_LOW_N 1.28777e-16
C1097 HS_N_10 FS_P_GATE 1.02198e-15
C1098 HS_N_10 VDD 5.35525e-15
C1099 PULLUP_N_CONTROL_S PULLDOWN_N_R 3.76421e-17
C1100 PULLUP_N_BLEED_0 PULLUP_N_GATE 2.01392e-16
C1101 PULLUP_N_OUT PULLUP_N 1.04554e-18
C1102 HS_N_6 HS_N_1 4.2943e-17
C1103 TERM_P_R HS_P_4 1.25403e-16
C1104 VDD TERM_OR_P_S 4.41026e-15
C1105 FS_N_BLEED_1 FS_HIGH_P 6.21526e-19
C1106 HS_N_9 FS_P_BLEED_4 4.79044e-17
C1107 TERM_VCM PAD_N 1.00205e-18
C1108 HS_N_11 HS_PBIAS 1.09598e-15
C1109 HS_N_10 HS_P_5 3.48887e-17
C1110 DIV_ENABLE PULLUP_P 5.06175e-17
C1111 HS_P HS_P_2 7.07711e-15
C1112 FS_P_OUT PAD_P 5.93556e-15
C1113 HS_P_6 HS_P_3 7.26076e-17
C1114 HS_PBIAS FS_LOW_P 3.43558e-16
C1115 TERM_GATE_N_BLEED_2 TERM_GATE_N_BLEED_1 7.29504e-15
C1116 HS_N_5 HS_P_6 5.82839e-17
C1117 PULLUP_N_OUT PULLUP_P_BLEED_3 2.82661e-19
C1118 PULLUP_N_OUT HS_P_8 4.29014e-17
C1119 FS_N_BLEED_1 FS_N_GATE 1.70709e-16
C1120 HS_N PULLUP_P_BLEED_4 4.82815e-17
C1121 HS_N_1 HS_P_2 6.48683e-18
C1122 FS_P_BLEED_3 FS_P_BLEED_6 6.06886e-17
C1123 VCM_LOW_OK PULLUP_P 7.11798e-17
C1124 TERM_ENABLE PULLUP_N_BLEED_5 1.16848e-17
C1125 FS_N_BLEED_2 HS_N 1.1535e-16
C1126 TERM_GATE_N_BLEED_2 TERM_ENABLE 7.92848e-17
C1127 HS_N_8 HS_P 5.9635e-16
C1128 HS_N_12 FS_P_GATE 1.01722e-15
C1129 HS_N_12 VDD 6.63817e-15
C1130 HS_N_8 HS_N_1 4.2943e-17
C1131 PULLUP_N PULLDOWN_P 5.71742e-15
C1132 PULLDOWN_N PULLUP_N 5.39744e-17
C1133 PULLUP_N_OUT PULLDOWN_N_R 1.20532e-16
C1134 PULLUP_N_CONTROL_S PULLUP_N_GATE 1.19294e-15
C1135 PULLUP_P_CONTROL_S PULLUP_P_BLEED_0 6.85274e-19
C1136 HS_N_9 HS_P_13 5.49271e-17
C1137 FS_P_GATE FS_N_OUT 3.55763e-16
C1138 PULLUP_N_OUT FS_P_BLEED_0 1.1535e-16
C1139 PULLUP_P_WELL HS_P 2.91847e-16
C1140 HS_PBIAS DIV_LOW_P 6.13173e-19
C1141 FS_N_BLEED_5 HS_P 8.85647e-17
C1142 HS_N_13 HS_PBIAS 4.9299e-15
C1143 DIFF_ENABLE HS_N 2.23167e-16
C1144 HS_P_6 TERM_GATE_P 1.55077e-16
C1145 HS_N_12 HS_P_5 3.48887e-17
C1146 VDD FS_N_OUT 1.19109e-14
C1147 TERM_ENABLE TERM_GATE_N_BLEED_1 4.881e-17
C1148 HS_N_7 HS_P_6 2.53634e-17
C1149 HS_N_1 PULLUP_P_WELL 2.30153e-16
C1150 PULLUP_P_OUT PULLDOWN_P_R 1.04805e-16
C1151 PULLUP_N_OUT HS_P_10 8.96075e-17
C1152 VCM_LOW_OK FS_P_BLEED_1 1.49741e-16
C1153 PULLUP_N_BLEED_5 PULLUP_N_BLEED_4 5.5147e-16
C1154 FS_P_BLEED_5 FS_P_BLEED_6 3.5401e-15
C1155 FS_P_BLEED_3 FS_HIGH_P 3.57681e-17
C1156 FS_N_OUT HS_P_5 6.16744e-17
C1157 FS_N_BLEED_1 HS_N 7.09674e-17
C1158 PULLUP_P_BLEED_1 PULLUP_P 2.71448e-16
C1159 PULLUP_P_BLEED_2 PULLUP_P_BLEED_3 2.29663e-15
C1160 HS_N_2 FS_P_GATE 1.01182e-15
C1161 TERM_VCM HS_P 2.3967e-16
C1162 TERM_GATE_N_BLEED_2 FS_LOW_N 8.39001e-17
C1163 PULLUP_N_OUT PULLUP_P_BLEED_5 9.19551e-17
C1164 HS_N_2 VDD 4.88268e-15
C1165 PULLDOWN_N PULLDOWN_N_R 5.82803e-15
C1166 PULLUP_N_OUT PULLUP_N_GATE 1.81444e-14
C1167 PULLDOWN_N_R PULLDOWN_P 8.74701e-14
C1168 HS_N_9 HS_P_8 1.04313e-16
C1169 TERM_VCM HS_N_1 1.64345e-16
C1170 VCM_LOW_OK HS_P_0 4.12239e-17
C1171 HS_N PULLUP_P_OUT 9.5159e-17
C1172 VDD PULLUP_P_CONTROL_S 7.26698e-15
C1173 HS_PBIAS HS_P_1 2.59892e-15
C1174 HS_N_3 HS_PBIAS 1.39899e-15
C1175 TERM_ENABLE TERM_OR_P_NS 1.64203e-16
C1176 TERM_ENABLE FS_N_BLEED_4 8.9543e-17
C1177 HS_N_2 HS_P_5 3.48887e-17
C1178 HS_P_11 HS_P_13 8.85142e-17
C1179 HS_P_7 PAD_P 1.52213e-15
C1180 PULLUP_N_BLEED_3 PULLUP_N_WELL 1.99646e-18
C1181 FS_LOW_N TERM_GATE_N_BLEED_1 7.12673e-17
C1182 HS_N_0 TERM_P_R 9.87585e-17
C1183 FS_N_BLEED_5 FS_N_BLEED_3 1.06333e-16
C1184 PULLUP_N_OUT FS_LOW_P 7.13152e-17
C1185 HS_N_9 PULLDOWN_N_R 2.40376e-17
C1186 HS_N_9 FS_P_BLEED_0 6.1779e-17
C1187 HS_N_4 FS_P_GATE 1.011e-15
C1188 TERM_ENABLE FS_LOW_N 2.377e-16
C1189 HS_N_6 PULLUP_P_BLEED_0 4.38619e-19
C1190 HS_N_4 VDD 5.66146e-15
C1191 PULLUP_P_BLEED_5 PULLDOWN_P 9.89305e-19
C1192 PULLDOWN_N PULLUP_N_GATE 1.32582e-18
C1193 PULLUP_N_GATE PULLDOWN_P 2.06889e-16
C1194 HS_N_9 HS_P_10 3.10917e-17
C1195 HS_N FS_P_BLEED_3 1.43109e-17
C1196 FS_LOW_N FS_N_BLEED_4 2.82661e-19
C1197 HS_PBIAS HS_P_3 6.23881e-15
C1198 HS_P_11 HS_P_8 7.92477e-18
C1199 FS_P_CONTROL_S FS_P_BLEED_0 4.29874e-17
C1200 FS_N_BLEED_0 FS_N_BLEED_5 1.05416e-16
C1201 HS_N_5 HS_PBIAS 2.62068e-15
C1202 HS_N_4 HS_P_5 3.51065e-17
C1203 HS_N_0 HS_N_10 2.19009e-15
C1204 PULLUP_N_BLEED_2 PULLUP_N_WELL 1.13798e-17
C1205 DIV_N HS_P_6 4.31015e-19
C1206 FS_P_BLEED_5 PULLDOWN_P_R 8.55331e-17
C1207 PULLUP_N_OUT HS_N_13 4.37656e-17
C1208 TERM_GATE_P_BLEED_0 HS_P_12 3.63569e-17
C1209 FS_P_GATE HS_P_12 5.99298e-18
C1210 HS_N_9 PULLUP_P_BLEED_5 5.2499e-17
C1211 DIV_ENABLE RX_N 7.43713e-16
C1212 VDD HS_P_12 4.79446e-15
C1213 HS_PBIAS PULLUP_N_BLEED_3 1.76792e-16
C1214 TERM_GATE_P_BLEED_0 HS_N_6 4.38619e-19
C1215 PULLDOWN_N_R HS_P_11 7.46551e-17
C1216 TERM_GATE_N_BLEED_2 HS_P 5.2499e-17
C1217 TERM_VCM TERM_GATE_N_BLEED_0 1.18622e-16
C1218 HS_N_8 PULLUP_P_BLEED_0 7.58005e-19
C1219 HS_N_6 FS_P_GATE 1.02474e-15
C1220 PULLUP_P_BLEED_3 PULLUP_P_BLEED_4 3.81017e-15
C1221 HS_N_6 VDD 6.5394e-15
C1222 HS_P_12 HS_P_5 3.88724e-17
C1223 PULLDOWN_N PULLUP_N_BLEED_6 8.324e-18
C1224 HS_N_4 HS_P_4 6.84267e-19
C1225 TERM_GATE_N_BLEED_2 HS_N_1 5.28587e-17
C1226 HS_N FS_P_BLEED_5 8.04284e-17
C1227 HS_N_9 HS_N_11 3.51103e-17
C1228 FS_HIGH_N BYPASS_ENABLE 1.04085e-19
C1229 PULLUP_N_BLEED_1 FS_HIGH_P 9.40038e-17
C1230 PULLUP_P_WELL PULLUP_P_BLEED_0 2.68055e-15
C1231 HS_PBIAS TERM_GATE_P 2.24085e-17
C1232 HS_N_7 HS_PBIAS 7.23833e-15
C1233 TERM_GATE_P_BLEED_0 HS_P_2 2.48309e-17
C1234 HS_N_6 HS_P_5 1.43705e-16
C1235 HS_P_11 HS_P_10 4.83384e-14
C1236 HS_N_9 FS_LOW_P 2.13257e-16
C1237 PULLUP_N DIFF_ENABLE 1.3679e-16
C1238 HS_N_0 HS_N_12 3.94226e-17
C1239 VDD HS_P_2 5.70999e-15
C1240 TERM_GATE_N_BLEED_1 HS_P 3.48887e-17
C1241 HS_N_13 PULLDOWN_P 4.42824e-17
C1242 PULLUP_N_OUT HS_P_1 5.94742e-17
C1243 FS_P_BLEED_6 PULLDOWN_P_R 1.12546e-16
C1244 PULLDOWN_N_R PULLUP_P_BLEED_4 5.46167e-17
C1245 PULLUP_N_OUT HS_N_3 2.32186e-18
C1246 FS_P_OUT DIV_ENABLE 6.28968e-17
C1247 HS_N_11 FS_P_CONTROL_S 3.23362e-17
C1248 HS_N_1 TERM_GATE_N_BLEED_1 3.48887e-17
C1249 PULLDOWN_N_R TERM_GATE_P_BLEED_1 1.94556e-18
C1250 FS_P_BLEED_4 FS_P_BLEED_3 4.60809e-16
C1251 HS_N_0 FS_N_OUT 6.16744e-17
C1252 HS_P_5 HS_P_2 3.14179e-17
C1253 HS_P_12 HS_P_4 6.21526e-19
C1254 HS_PBIAS PULLUP_N_BLEED_2 7.92848e-17
C1255 FS_N_BLEED_2 PULLDOWN_N_R 5.18804e-17
C1256 TERM_GATE_P_BLEED_0 HS_N_8 7.58005e-19
C1257 FS_P_WELL DIV_ENABLE 9.4004e-17
C1258 FS_N_GATE FS_HIGH_P 4.25584e-17
C1259 HS_N_8 FS_P_GATE 1.03439e-15
C1260 TERM_ENABLE HS_P 5.44104e-17
C1261 FS_P_OUT VCM_LOW_OK 4.13132e-16
C1262 TERM_P_R PAD_P 1.55448e-16
C1263 HS_N_8 VDD 5.59851e-15
C1264 PULLUP_N_BLEED_0 PULLUP_N_BLEED_2 3.06736e-19
C1265 HS_N_6 HS_P_4 3.73763e-17
C1266 TERM_ENABLE HS_N_1 1.06073e-16
C1267 HS_N FS_P_BLEED_6 8.04284e-17
C1268 HS_N_9 HS_N_13 1.5155e-16
C1269 FS_P_GATE PULLUP_P_WELL 5.65411e-18
C1270 VCM_LOW_OK FS_P_WELL 1.37203e-15
C1271 TERM_GATE_N HS_PBIAS 1.74562e-16
C1272 FS_N_BLEED_4 HS_P 8.85647e-17
C1273 HS_P TERM_OR_P_NS 4.05633e-17
C1274 PULLUP_N_WELL TERM_N_R 2.84306e-16
C1275 VDD PULLUP_P_WELL 2.95037e-14
C1276 PULLDOWN_N_R DIFF_ENABLE 1.83335e-19
C1277 HS_N_8 HS_P_5 5.89263e-17
C1278 HS_N_0 HS_N_2 3.92532e-17
C1279 HS_N_11 HS_P_11 6.80583e-17
C1280 VDD FS_N_BLEED_5 5.54309e-16
C1281 PULLUP_N_OUT HS_P_3 8.63334e-17
C1282 PULLUP_P_BLEED_5 PULLUP_P_BLEED_4 6.36804e-15
C1283 HS_P_0 TERM_OR_P_B 9.38414e-17
C1284 HS_P_2 HS_P_4 3.98637e-17
C1285 PULLUP_N_OUT HS_N_5 1.84015e-17
C1286 HS_P_11 FS_LOW_P 5.23872e-17
C1287 HS_N_13 FS_P_CONTROL_S 3.22599e-17
C1288 HS_N_0 PULLUP_P_CONTROL_S 3.48887e-17
C1289 FS_N_CONTROL_S TERM_N_R 5.8592e-17
C1290 FS_N_BLEED_6 TERM_P_R 4.76598e-17
C1291 PULLUP_P_OUT HS_P_8 1.35418e-18
C1292 FS_P_BLEED_4 FS_P_BLEED_5 1.99363e-15
C1293 PULLUP_N_BLEED_1 HS_N 6.16744e-17
C1294 PULLUP_N_BLEED_4 HS_P 2.11937e-18
C1295 TERM_GATE_N_BLEED_2 TERM_GATE_N_BLEED_0 3.06736e-19
C1296 FS_LOW_N HS_P 4.57398e-17
C1297 HS_N_10 PAD_P 1.19493e-16
C1298 FS_N_BLEED_6 FS_HIGH_N 1.66096e-16
C1299 TERM_VCM FS_P_GATE 6.24859e-16
C1300 TERM_OR_N_S TERM_P_R 3.05505e-16
C1301 TERM_VCM VDD 4.03485e-14
C1302 HS_N_11 PULLUP_P_BLEED_4 3.48887e-17
C1303 PULLUP_N_OUT PULLUP_N_BLEED_3 1.30789e-20
C1304 HS_N_8 HS_P_4 2.40376e-17
C1305 HS_N_9 HS_P_1 3.12002e-17
C1306 FS_LOW_N HS_N_1 4.62644e-17
C1307 HS_PBIAS PULLUP_P_BLEED_6 1.74058e-16
C1308 HS_N_9 HS_N_3 3.33161e-18
C1309 PULLDOWN_N_R PULLUP_P_OUT 4.9012e-17
C1310 FS_LOW_P PULLUP_P_BLEED_4 6.86613e-17
C1311 HS_N FS_HIGH_P 9.39679e-19
C1312 TERM_ENABLE FS_N_BLEED_3 1.16848e-17
C1313 DIV_N HS_PBIAS 1.39005e-16
C1314 TERM_VCM HS_P_5 9.61503e-17
C1315 HS_P PAD_N 1.82423e-15
C1316 FS_P_BLEED_0 PULLUP_P_OUT 1.46146e-16
C1317 HS_N_0 HS_N_4 3.91881e-17
C1318 FS_N_BLEED_2 FS_LOW_P 1.44632e-16
C1319 FS_N_GATE HS_N 2.05519e-15
C1320 TERM_GATE_N_BLEED_0 TERM_GATE_N_BLEED_1 2.88199e-15
C1321 HS_N_5 PULLDOWN_P 5.30255e-17
C1322 HS_N_1 PAD_N 1.13339e-15
C1323 PULLUP_N_OUT TERM_GATE_P 3.7427e-16
C1324 PULLUP_N_OUT HS_N_7 5.81182e-17
C1325 PULLUP_P_OUT HS_P_10 5.27608e-17
C1326 HS_N_3 FS_P_CONTROL_S 3.22599e-17
C1327 FS_N_OUT RX_P 1.28425e-17
C1328 FS_P_BLEED_4 FS_P_BLEED_6 1.20364e-16
C1329 FS_N_BLEED_4 FS_N_BLEED_3 6.17691e-15
C1330 TERM_GATE_P_BLEED_2 TERM_VCM 2.19364e-17
C1331 HS_PBIAS TERM_N_R 8.22978e-16
C1332 TERM_ENABLE TERM_GATE_N_BLEED_0 2.0615e-18
C1333 HS_P_7 VCM_LOW_OK 3.48887e-17
C1334 FS_P_BLEED_2 HS_PBIAS 4.81135e-17
C1335 TERM_OR_N_S HS_N_10 6.33501e-17
C1336 TERM_OR_N_B TERM_P_R 3.6281e-16
C1337 HS_N_12 PAD_P 2.18792e-15
C1338 DIFF_ENABLE FS_LOW_P 2.20905e-16
C1339 HS_N_13 PULLUP_P_BLEED_4 3.48887e-17
C1340 PULLUP_N_BLEED_0 TERM_N_R 1.14443e-16
C1341 HS_N PULLDOWN_P_R 4.38785e-17
C1342 TERM_VCM HS_P_4 1.24612e-16
C1343 HS_N_0 HS_P_12 7.54702e-17
C1344 PULLUP_N_BLEED_3 PULLDOWN_P 6.51694e-17
C1345 FS_N_WELL TERM_P_R 1.52918e-15
C1346 HS_N_9 HS_P_3 3.08895e-17
C1347 HS_N_9 HS_N_5 4.07931e-17
C1348 FS_LOW_N FS_N_BLEED_3 4.04393e-19
C1349 FS_N_BLEED_0 FS_N_BLEED_4 1.22122e-16
C1350 DIV_LOW_N HS_PBIAS 1.04595e-16
C1351 HS_P_11 HS_P_1 5.93509e-17
C1352 FS_N_OUT PAD_P 1.79266e-16
C1353 HS_N_0 HS_N_6 3.91118e-17
C1354 FS_N_BLEED_1 FS_LOW_P 2.37672e-16
C1355 FS_N_WELL FS_HIGH_N 6.32864e-16
C1356 TERM_P_R PULLUP_P_GATE 2.08715e-16
C1357 HS_N_7 PULLDOWN_P 4.42824e-17
C1358 PULLUP_N_OUT TERM_GATE_N 2.7495e-16
C1359 HS_N_5 FS_P_CONTROL_S 3.22599e-17
C1360 HS_N_11 PULLUP_P_OUT 2.5076e-17
C1361 FS_LOW_P PULLUP_P_OUT 6.60399e-17
C1362 TERM_OR_N_S HS_N_12 6.33501e-17
C1363 TERM_OR_N_B HS_N_10 3.02657e-17
C1364 HS_N_2 PAD_P 1.25659e-15
C1365 FS_LOW_N FS_N_BLEED_0 8.4917e-17
C1366 HS_N_3 PULLUP_P_BLEED_4 3.48887e-17
C1367 PULLUP_N_BLEED_2 PULLDOWN_P 6.51694e-17
C1368 HS_N_10 FS_N_WELL 1.99681e-17
C1369 HS_N_1 HS_P 1.78922e-16
C1370 HS_N_9 TERM_GATE_P 1.36047e-16
C1371 HS_N_9 HS_N_7 4.1513e-17
C1372 PULLDOWN_N_R FS_P_BLEED_5 5.93072e-17
C1373 TERM_OR_N_S FS_N_OUT 6.83005e-17
C1374 FS_P_OUT TERM_OR_P_B 1.61216e-16
C1375 HS_N_5 HS_P_11 3.08895e-17
C1376 HS_P_11 HS_P_3 2.87722e-17
C1377 HS_N_10 PULLUP_P_GATE 7.41399e-17
C1378 PULLUP_N_OUT PULLUP_P_BLEED_6 9.19551e-17
C1379 HS_N_0 HS_N_8 3.91118e-17
C1380 TERM_GATE_N PULLDOWN_P 1.79027e-16
C1381 VDD TERM_GATE_N_BLEED_1 4.51879e-16
C1382 PULLUP_N_OUT DIV_N 4.44725e-19
C1383 HS_N_7 FS_P_CONTROL_S 3.22599e-17
C1384 HS_N_13 PULLUP_P_OUT 2.4636e-17
C1385 HS_N_11 FS_P_BLEED_3 1.63187e-19
C1386 HS_N_0 PULLUP_P_WELL 3.82375e-16
C1387 TERM_GATE_P_BLEED_0 TERM_ENABLE 9.80321e-17
C1388 PULLUP_N PULLUP_N_BLEED_1 5.49262e-16
C1389 FS_LOW_P FS_P_BLEED_3 7.81006e-17
C1390 TERM_ENABLE FS_P_GATE 1.01177e-15
C1391 TERM_OR_N_S HS_N_2 6.33501e-17
C1392 TERM_OR_N_B HS_N_12 2.94444e-17
C1393 HS_N_4 PAD_P 6.51672e-17
C1394 HS_N_5 PULLUP_P_BLEED_4 3.48887e-17
C1395 PULLUP_N_OUT TERM_N_R 2.96166e-16
C1396 TERM_ENABLE VDD 1.47304e-14
C1397 HS_N_12 FS_N_WELL 2.01404e-17
C1398 TERM_P_R DIV_ENABLE 4.57093e-19
C1399 TERM_N_R TERM_OR_N_NS 3.61354e-18
C1400 PULLUP_N_OUT FS_P_BLEED_2 6.15064e-17
C1401 HS_N_9 TERM_GATE_N 5.60255e-17
C1402 FS_P_BLEED_4 HS_N 4.62963e-17
C1403 PULLDOWN_N_R FS_P_BLEED_6 1.03778e-16
C1404 FS_N_BLEED_3 HS_P 8.85647e-17
C1405 HS_P_11 TERM_GATE_P 1.73603e-16
C1406 TERM_ENABLE HS_P_5 2.40376e-17
C1407 HS_N_7 HS_P_11 1.52593e-19
C1408 VDD TERM_OR_P_NS 4.36598e-17
C1409 HS_N_0 TERM_VCM 1.84191e-16
C1410 VDD FS_N_BLEED_4 1.56976e-17
C1411 PULLUP_P_BLEED_6 PULLDOWN_P 5.12217e-18
C1412 HS_N_12 PULLUP_P_GATE 7.3256e-17
C1413 HS_P_13 PULLDOWN_P_R 2.40376e-17
C1414 FS_N_WELL FS_N_OUT 2.2665e-13
C1415 HS_P_7 HS_P_9 2.0615e-18
C1416 FS_HIGH_N DIV_ENABLE 3.74927e-15
C1417 PULLUP_N_WELL PULLUP_P 8.30565e-15
C1418 DIV_N PULLDOWN_P 4.61315e-17
C1419 PULLUP_N_OUT DIV_LOW_N 4.91138e-17
C1420 PAD_P HS_P_12 1.66835e-15
C1421 TERM_P_R VCM_LOW_OK 3.48359e-16
C1422 HS_N_11 FS_P_BLEED_5 6.1779e-17
C1423 HS_N_3 PULLUP_P_OUT 2.40376e-17
C1424 HS_P_6 HS_P_0 4.60348e-17
C1425 HS_P_5 TERM_OR_P_NS 2.84614e-17
C1426 FS_N_OUT PULLUP_P_GATE 5.08233e-17
C1427 PULLDOWN_N_R PULLUP_N_BLEED_1 4.84837e-17
C1428 FS_N_CONTROL_S PULLUP_P 1.04601e-16
C1429 TERM_GATE_P_BLEED_2 TERM_ENABLE 7.30603e-17
C1430 TERM_OR_N_S HS_N_4 6.53108e-17
C1431 TERM_OR_N_B HS_N_2 2.90536e-17
C1432 HS_N_6 PAD_P 2.14046e-15
C1433 FS_LOW_N VDD 1.92525e-15
C1434 HS_N_7 PULLUP_P_BLEED_4 3.48887e-17
C1435 TERM_N_R PULLDOWN_P 3.16037e-16
C1436 PULLDOWN_N TERM_N_R 2.06963e-16
C1437 TERM_GATE_P_BLEED_1 TERM_GATE_P 3.76164e-16
C1438 HS_N_9 PULLUP_P_BLEED_6 4.86947e-17
C1439 TERM_ENABLE HS_P_4 7.92264e-17
C1440 PULLUP_P_WELL BYPASS_ENABLE 8.22717e-18
C1441 HS_N_10 DIV_ENABLE 3.18186e-17
C1442 HS_N_9 DIV_N 3.31088e-17
C1443 HS_N HS_P_13 3.53743e-16
C1444 HS_P_7 TERM_OR_P_B 1.01166e-16
C1445 HS_N_2 PULLUP_P_GATE 7.25839e-17
C1446 PAD_P HS_P_2 1.20139e-15
C1447 FS_P_BLEED_0 FS_HIGH_P 1.42453e-17
C1448 TERM_N_R PULLUP_P_BLEED_2 5.72918e-17
C1449 VDD PAD_N 4.57162e-18
C1450 HS_N_10 VCM_LOW_OK 3.48887e-17
C1451 HS_P_4 TERM_OR_P_NS 2.84614e-17
C1452 HS_P_8 PULLDOWN_P_R 8.55367e-17
C1453 PULLDOWN_N_R FS_N_GATE 1.21497e-15
C1454 DIV_LOW_N PULLDOWN_P 8.77472e-17
C1455 PULLUP_P_CONTROL_S PULLUP_P_GATE 1.59532e-15
C1456 PULLUP_P_OUT HS_P_3 5.27608e-17
C1457 HS_N_13 FS_P_BLEED_5 6.1779e-17
C1458 HS_N_11 FS_P_BLEED_6 6.1779e-17
C1459 HS_N_5 PULLUP_P_OUT 2.40376e-17
C1460 VCM_LOW_OK TERM_OR_P_S 1.87923e-15
C1461 HS_N_9 TERM_N_R 5.94779e-17
C1462 TERM_VCM BYPASS_ENABLE 8.88787e-18
C1463 HS_P_5 PAD_N 1.55482e-15
C1464 PULLUP_N_GATE PULLUP_N_BLEED_1 1.81408e-16
C1465 HS_N_9 FS_P_BLEED_2 3.47206e-17
C1466 TERM_OR_N_B HS_N_4 2.84614e-17
C1467 HS_PBIAS PULLUP_P 3.12738e-16
C1468 TERM_OR_N_S HS_N_6 6.68586e-17
C1469 HS_N_8 PAD_P 4.35222e-16
C1470 HS_P PULLUP_P_BLEED_0 1.53654e-18
C1471 PULLDOWN_N_R PULLDOWN_P_R 3.30605e-14
C1472 PULLUP_P_BLEED_5 FS_HIGH_P 3.57681e-17
C1473 HS_N HS_P_8 1.90156e-16
C1474 HS_N_12 DIV_ENABLE 3.14337e-17
C1475 FS_P_BLEED_0 PULLDOWN_P_R 1.01235e-16
C1476 HS_N_9 DIV_LOW_N 6.1779e-17
C1477 PULLUP_N_BLEED_0 PULLUP_P 1.04417e-16
C1478 FS_N_BLEED_0 FS_N_BLEED_3 1.187e-16
C1479 PULLUP_N_GATE FS_HIGH_P 4.15499e-18
C1480 FS_P_BLEED_2 FS_P_CONTROL_S 7.39879e-19
C1481 HS_N_4 PULLUP_P_GATE 7.21128e-17
C1482 PULLUP_N_BLEED_1 FS_LOW_P 6.27135e-17
C1483 HS_N_0 TERM_GATE_N_BLEED_2 5.29295e-17
C1484 HS_P_10 PULLDOWN_P_R 7.46551e-17
C1485 HS_N_12 VCM_LOW_OK 3.48887e-17
C1486 FS_N_OUT DIV_ENABLE 1.53763e-16
C1487 HS_P_4 PAD_N 2.77347e-16
C1488 PULLUP_P_OUT TERM_GATE_P 4.0537e-16
C1489 HS_PBIAS FS_P_BLEED_1 8.85647e-17
C1490 HS_N_3 FS_P_BLEED_5 6.1779e-17
C1491 HS_N_13 FS_P_BLEED_6 6.1779e-17
C1492 HS_N_7 PULLUP_P_OUT 2.40376e-17
C1493 HS_N_11 FS_HIGH_P 3.07681e-19
C1494 PULLDOWN_N_R HS_N 3.05505e-17
C1495 FS_LOW_P FS_HIGH_P 8.66124e-15
C1496 TERM_GATE_P_BLEED_0 HS_P 1.53654e-18
C1497 VCM_LOW_OK FS_N_OUT 6.16744e-17
C1498 TERM_N_R HS_P_11 5.72216e-17
C1499 HS_N FS_P_BLEED_0 7.7631e-17
C1500 TERM_OR_N_B HS_N_6 2.84614e-17
C1501 TERM_OR_N_S HS_N_8 7.03885e-17
C1502 HS_N_11 FS_N_GATE 1.48783e-17
C1503 TERM_VCM PAD_P 2.70139e-18
C1504 FS_N_BLEED_6 FS_N_BLEED_5 9.22595e-15
C1505 PULLUP_P_BLEED_4 PULLUP_P_BLEED_6 1.53064e-18
C1506 FS_P_GATE HS_P 1.05516e-15
C1507 HS_N_0 TERM_GATE_N_BLEED_1 3.48887e-17
C1508 PULLUP_P_BLEED_5 PULLDOWN_P_R 9.20433e-17
C1509 DIV_N PULLUP_P_BLEED_4 1.0151e-16
C1510 VDD HS_P 1.70325e-15
C1511 HS_N_2 DIV_ENABLE 3.08895e-17
C1512 FS_N_GATE FS_LOW_P 4.04336e-16
C1513 FS_P_GATE HS_N_1 1.02597e-15
C1514 TERM_P_R HS_P_9 1.15683e-16
C1515 HS_N HS_P_10 3.44984e-16
C1516 HS_N_1 VDD 5.27575e-15
C1517 PULLUP_N_CONTROL_S PULLUP_P 1.10536e-18
C1518 HS_N_6 PULLUP_P_GATE 7.4292e-17
C1519 FS_P_OUT HS_P_6 1.56749e-16
C1520 HS_P HS_P_5 5.05127e-15
C1521 HS_N_0 TERM_ENABLE 1.03356e-16
C1522 HS_PBIAS HS_P_0 9.48826e-16
C1523 HS_N_2 VCM_LOW_OK 3.48887e-17
C1524 TERM_N_R PULLUP_P_BLEED_4 6.10527e-17
C1525 HS_N_1 HS_P_5 3.48887e-17
C1526 FS_N_BLEED_6 TERM_VCM 4.26329e-17
C1527 HS_N_11 PULLDOWN_P_R 2.4295e-17
C1528 TERM_N_R TERM_GATE_P_BLEED_1 2.37672e-16
C1529 HS_N_3 FS_P_BLEED_6 6.1779e-17
C1530 HS_N_5 FS_P_BLEED_5 6.21895e-17
C1531 FS_LOW_P PULLDOWN_P_R 6.53881e-17
C1532 VCM_LOW_OK PULLUP_P_CONTROL_S 3.76229e-17
C1533 HS_N PULLUP_P_BLEED_5 1.02101e-16
C1534 PULLUP_N_GATE HS_N 1.79717e-16
C1535 TERM_P_R TERM_OR_P_B 7.68571e-16
C1536 TERM_OR_N_S TERM_VCM 6.06589e-19
C1537 TERM_OR_N_B HS_N_8 2.8794e-17
C1538 HS_N_13 FS_N_GATE 1.99454e-16
C1539 HS_N_4 DIV_ENABLE 3.08895e-17
C1540 HS_N DIV_P 8.00466e-17
C1541 HS_P HS_P_4 1.7567e-15
C1542 PULLUP_N_OUT PULLUP_P 2.95964e-14
C1543 HS_N_11 HS_N 5.51295e-15
C1544 TERM_GATE_N_BLEED_1 BYPASS_ENABLE 7.65665e-18
C1545 TERM_N_R DIFF_ENABLE 4.32386e-15
C1546 HS_N FS_LOW_P 1.00151e-16
C1547 HS_N_0 FS_LOW_N 4.60839e-17
C1548 HS_N_8 PULLUP_P_GATE 7.58493e-17
C1549 FS_N_WELL FS_N_BLEED_5 1.63187e-19
C1550 HS_N_13 PULLDOWN_P_R 2.40376e-17
C1551 HS_N_4 VCM_LOW_OK 3.48887e-17
C1552 HS_P_13 HS_P_8 5.62374e-17
C1553 HS_N_5 FS_P_BLEED_6 6.1779e-17
C1554 PULLUP_P_WELL PULLUP_P_GATE 3.5879e-14
C1555 HS_N_7 FS_P_BLEED_5 6.24551e-17
C1556 HS_N_0 PAD_N 1.42664e-15
C1557 PULLUP_P_CONTROL_S PULLUP_P_BLEED_1 5.13095e-19
C1558 TERM_OR_N_B TERM_VCM 2.4558e-17
C1559 HS_N_10 TERM_OR_P_B 7.38007e-17
C1560 PULLUP_N_OUT FS_P_BLEED_1 1.1535e-16
C1561 VDD FS_N_BLEED_0 3.14506e-19
C1562 TERM_OR_P_B TERM_OR_P_S 1.83456e-15
C1563 TERM_GATE_N_BLEED_0 VDD 9.72159e-16
C1564 TERM_VCM FS_N_WELL 2.07239e-15
C1565 HS_N_6 DIV_ENABLE 3.08895e-17
C1566 PULLDOWN_N_R HS_P_13 2.40376e-17
C1567 VCM_LOW_OK HS_P_12 3.48887e-17
C1568 HS_N DIV_LOW_P 6.61104e-17
C1569 HS_N_13 HS_N 9.82024e-16
C1570 TERM_N_R PULLUP_P_OUT 1.42869e-16
C1571 PULLDOWN_N PULLUP_P 6.10321e-17
C1572 FS_P_BLEED_2 PULLUP_P_OUT 5.902e-17
C1573 TERM_VCM PULLUP_P_GATE 1.69661e-16
C1574 HS_P_7 HS_P_6 3.16746e-14
C1575 HS_P_1 PULLDOWN_P_R 8.5948e-17
C1576 HS_N_6 VCM_LOW_OK 3.54947e-17
C1577 HS_N_3 PULLDOWN_P_R 2.40376e-17
C1578 PULLUP_P_BLEED_2 PULLUP_P 1.44632e-16
C1579 HS_N_7 FS_P_BLEED_6 6.1779e-17
C1580 HS_P_13 HS_P_10 9.46803e-17
C1581 DIV_N FS_P_BLEED_3 6.00678e-19
C1582 PULLUP_N_OUT HS_P_0 9.23731e-17
C1583 HS_N_11 FS_P_BLEED_4 2.90019e-17
C1584 PULLUP_N PULLDOWN_N_R 9.20472e-17
C1585 PULLUP_N_BLEED_3 PULLUP_N_BLEED_1 1.53064e-18
C1586 HS_N_12 TERM_OR_P_B 7.3066e-17
C1587 VCM_LOW_OK HS_P_2 3.48887e-17
C1588 VDD PULLUP_P_BLEED_0 4.79522e-18
C1589 HS_N_8 DIV_ENABLE 3.08895e-17
C1590 HS_N HS_P_1 7.50264e-16
C1591 FS_N_OUT TERM_OR_P_B 5.08233e-17
C1592 PULLDOWN_N_R HS_P_8 6.54378e-17
C1593 BYPASS_ENABLE PAD_N 1.16927e-14
C1594 HS_N_3 HS_N 2.50774e-15
C1595 FS_P_OUT HS_PBIAS 9.82031e-16
C1596 FS_P_BLEED_2 FS_P_BLEED_3 1.49098e-15
C1597 HS_P_3 PULLDOWN_P_R 7.46551e-17
C1598 PULLUP_P_WELL DIV_ENABLE 1.34291e-17
C1599 HS_N_0 HS_P 1.61812e-16
C1600 HS_N_5 PULLDOWN_P_R 2.40376e-17
C1601 FS_N_BLEED_6 TERM_ENABLE 6.15064e-17
C1602 HS_N_8 VCM_LOW_OK 3.58883e-17
C1603 HS_PBIAS FS_P_WELL 3.64298e-15
C1604 HS_P_8 HS_P_10 9.26191e-18
C1605 HS_N_0 HS_N_1 1.24629e-13
C1606 HS_N_9 FS_P_BLEED_1 6.1779e-17
C1607 HS_N_13 FS_P_BLEED_4 2.84614e-17
C1608 HS_N_11 HS_P_13 2.48708e-17
C1609 PAD_N RX_P 1.46409e-15
C1610 PULLUP_N_BLEED_2 PULLUP_N_BLEED_1 5.20556e-15
C1611 PULLUP_P_WELL VCM_LOW_OK 3.19449e-16
C1612 FS_LOW_P HS_P_13 4.60078e-17
C1613 PULLUP_N PULLUP_N_GATE 1.51486e-15
C1614 PULLDOWN_N_R FS_P_BLEED_0 1.01235e-16
C1615 HS_N_2 TERM_OR_P_B 7.25839e-17
C1616 FS_N_BLEED_6 FS_N_BLEED_4 8.54567e-18
C1617 TERM_OR_N_S TERM_ENABLE 7.06942e-15
C1618 TERM_GATE_P_BLEED_0 VDD 1.21311e-16
C1619 FS_P_GATE VDD 2.88962e-14
C1620 FS_P_CONTROL_S FS_P_BLEED_1 2.75956e-18
C1621 PULLUP_P_BLEED_5 PULLUP_P_BLEED_3 3.06736e-19
C1622 TERM_VCM DIV_ENABLE 2.24901e-16
C1623 PULLDOWN_N_R HS_P_10 7.46551e-17
C1624 HS_N HS_P_3 2.78047e-16
C1625 HS_N_5 HS_N 4.65354e-15
C1626 PULLUP_N_BLEED_2 FS_HIGH_P 1.34735e-17
C1627 TERM_GATE_P_BLEED_0 HS_P_5 2.4398e-17
C1628 PAD_P PAD_N 3.8984e-14
C1629 TERM_OR_N_B TERM_GATE_N_BLEED_1 4.43349e-19
C1630 HS_N_9 HS_P_0 3.79083e-17
C1631 VDD HS_P_5 4.75837e-15
C1632 TERM_VCM VCM_LOW_OK 1.04222e-13
C1633 TERM_GATE_P PULLDOWN_P_R 3.01434e-16
C1634 HS_N_7 PULLDOWN_P_R 2.40376e-17
C1635 FS_N_BLEED_6 FS_LOW_N 7.13436e-17
C1636 HS_N_13 HS_P_13 2.45032e-17
C1637 TERM_GATE_N FS_HIGH_P 4.15499e-18
C1638 PULLUP_P PULLUP_P_BLEED_4 2.24569e-16
C1639 PULLDOWN_N_R PULLUP_P_BLEED_5 9.19551e-17
C1640 HS_N_3 FS_P_BLEED_4 3.16784e-17
C1641 TERM_GATE_P_BLEED_0 TERM_GATE_P_BLEED_2 1.07587e-16
C1642 FS_LOW_P HS_P_8 4.566e-17
C1643 PULLUP_N PULLUP_N_BLEED_6 5.62374e-17
C1644 PULLUP_N_BLEED_3 HS_N 6.38681e-17
C1645 PULLDOWN_N_R PULLUP_N_GATE 1.24845e-15
C1646 HS_N_4 TERM_OR_P_B 7.21128e-17
C1647 TERM_OR_N_S FS_LOW_N 5.41599e-16
C1648 TERM_OR_N_B TERM_ENABLE 3.87396e-16
C1649 TERM_GATE_P_BLEED_2 VDD 8.40041e-17
C1650 PULLUP_P_WELL PULLUP_P_BLEED_1 1.22853e-16
C1651 TERM_GATE_P_BLEED_0 HS_P_4 2.45087e-17
C1652 TERM_P_R HS_P_6 8.35623e-17
C1653 TERM_ENABLE FS_N_WELL 2.797e-15
C1654 VDD HS_P_4 4.77793e-15
C1655 HS_N TERM_GATE_P 1.75618e-16
C1656 HS_N_11 PULLDOWN_N_R 2.40376e-17
C1657 HS_N_7 HS_N 6.94187e-16
C1658 HS_PBIAS HS_P_7 7.84988e-16
C1659 PULLDOWN_N_R DIV_P 1.29874e-17
C1660 PULLDOWN_N_R FS_LOW_P 6.29017e-17
C1661 HS_N_11 FS_P_BLEED_0 6.1779e-17
C1662 TERM_ENABLE PULLUP_P_GATE 8.88041e-16
C1663 DIFF_ENABLE PULLUP_P 6.60983e-17
C1664 PULLUP_N_OUT FS_P_OUT 5.83221e-16
C1665 HS_P_9 HS_P_2 4.19e-17
C1666 HS_P_12 TERM_OR_P_B 1.30594e-16
C1667 HS_P_11 HS_P_0 6.44472e-17
C1668 HS_P_5 HS_P_4 3.29896e-14
C1669 HS_P_13 HS_P_1 1.13522e-16
C1670 HS_N_3 HS_P_13 2.40376e-17
C1671 DIV_N FS_HIGH_P 8.52636e-15
C1672 HS_N_11 HS_P_10 1.40305e-16
C1673 HS_N_5 FS_P_BLEED_4 3.39226e-17
C1674 TERM_N_R PULLUP_N_BLEED_1 6.10527e-17
C1675 PULLUP_N_BLEED_2 HS_N 1.29428e-16
C1676 PULLUP_N_OUT FS_P_WELL 2.65152e-15
C1677 FS_LOW_P HS_P_10 5.50896e-17
C1678 PULLDOWN_N_R PULLUP_N_BLEED_6 8.24271e-17
C1679 HS_N_6 TERM_OR_P_B 7.21128e-17
C1680 TERM_OR_N_B FS_LOW_N 1.10292e-15
C1681 HS_N_10 HS_P_6 5.97008e-17
C1682 HS_P PAD_P 3.98004e-14
C1683 FS_LOW_N FS_N_WELL 1.02684e-15
C1684 HS_N_8 HS_P_9 6.48683e-18
C1685 HS_N_1 PAD_P 4.82136e-16
C1686 TERM_GATE_N_BLEED_2 DIV_ENABLE 2.67272e-19
C1687 TERM_N_R FS_HIGH_P 9.47315e-17
C1688 TERM_GATE_N HS_N 8.6863e-17
C1689 HS_N_11 PULLUP_P_BLEED_5 5.26622e-17
C1690 HS_N_13 PULLDOWN_N_R 6.83199e-17
C1691 HS_P_2 TERM_OR_P_B 1.03068e-16
C1692 PULLUP_P PULLUP_P_OUT 5.45617e-18
C1693 PULLUP_P_BLEED_5 FS_LOW_P 7.81006e-17
C1694 FS_P_BLEED_2 FS_HIGH_P 1.66126e-16
C1695 HS_N_13 FS_P_BLEED_0 6.1779e-17
C1696 FS_N_GATE TERM_N_R 8.17641e-16
C1697 PULLUP_P_BLEED_6 PULLDOWN_P_R 9.39536e-17
C1698 PULLUP_N_GATE FS_LOW_P 4.93931e-17
C1699 PULLUP_N_WELL TERM_P_R 2.52823e-16
C1700 HS_P_8 HS_P_1 2.40376e-17
C1701 HS_P_13 HS_P_3 2.65102e-16
C1702 FS_N_BLEED_6 HS_P 4.81135e-17
C1703 HS_N_5 HS_P_13 5.49271e-17
C1704 DIV_LOW_N FS_HIGH_P 1.65342e-16
C1705 TERM_GATE_N_BLEED_1 DIV_ENABLE 1.37454e-17
C1706 FS_N_CONTROL_S TERM_P_R 4.14006e-17
C1707 PULLUP_N_WELL FS_HIGH_N 1.41894e-16
C1708 HS_N_7 FS_P_BLEED_4 3.87195e-17
C1709 PULLUP_N_GATE PULLUP_N_BLEED_6 3.03119e-15
C1710 FS_LOW_P DIV_P 2.36145e-15
C1711 HS_N_11 FS_LOW_P 8.50523e-17
C1712 HS_N_8 TERM_OR_P_B 7.24454e-17
C1713 TERM_OR_N_S HS_P 9.56294e-17
C1714 HS_N_12 HS_P_6 5.90623e-17
C1715 FS_N_CONTROL_S FS_HIGH_N 5.89986e-15
C1716 FS_P_BLEED_1 PULLUP_P_OUT 1.10378e-16
C1717 TERM_OR_N_S HS_N_1 6.33501e-17
C1718 HS_N PULLUP_P_BLEED_6 5.04752e-17
C1719 HS_N_13 PULLUP_P_BLEED_5 5.2499e-17
C1720 HS_N_9 FS_P_OUT 4.33772e-16
C1721 TERM_VCM HS_P_9 1.40495e-16
C1722 TERM_ENABLE DIV_ENABLE 3.19248e-17
C1723 HS_N_3 PULLDOWN_N_R 2.40376e-17
C1724 FS_P_BLEED_2 PULLDOWN_P_R 5.44487e-17
C1725 PULLDOWN_N_R HS_P_1 6.54378e-17
C1726 DIV_N HS_N 4.97739e-17
C1727 HS_P_6 FS_N_OUT 6.16744e-17
C1728 HS_N_3 FS_P_BLEED_0 6.1779e-17
C1729 HS_N_0 FS_P_GATE 1.01462e-15
C1730 PULLUP_N_OUT HS_P_7 2.84614e-17
C1731 HS_N_9 FS_P_WELL 1.99234e-15
C1732 FS_P_OUT FS_P_CONTROL_S 7.9114e-19
C1733 TERM_ENABLE VCM_LOW_OK 1.50477e-16
C1734 HS_N_0 VDD 4.92907e-15
C1735 HS_P_10 HS_P_1 3.70279e-14
C1736 HS_P_8 HS_P_3 3.10917e-17
C1737 DIV_P DIV_LOW_P 5.03985e-16
C1738 HS_P_13 TERM_GATE_P 1.57749e-16
C1739 HS_N_7 HS_P_13 2.40376e-17
C1740 HS_N_11 DIV_LOW_P 1.842e-18
C1741 TERM_N_R HS_N 2.79477e-16
C1742 HS_N_11 HS_N_13 1.05138e-16
C1743 HS_N_0 HS_P_5 3.48887e-17
C1744 PULLUP_N PULLUP_N_BLEED_3 1.89753e-16
C1745 HS_PBIAS TERM_P_R 5.42172e-16
C1746 FS_LOW_P DIV_LOW_P 1.25454e-16
C1747 HS_N_13 FS_LOW_P 8.50523e-17
C1748 FS_P_BLEED_2 HS_N 4.40453e-17
C1749 TERM_VCM TERM_OR_P_B 6.30322e-17
C1750 TERM_OR_N_B HS_P 2.90384e-17
C1751 FS_P_WELL FS_P_CONTROL_S 1.94786e-16
C1752 VCM_LOW_OK TERM_OR_P_NS 2.92632e-15
C1753 FS_N_BLEED_6 FS_N_BLEED_3 7.80014e-18
C1754 HS_N_2 HS_P_6 5.87551e-17
C1755 FS_P_BLEED_1 FS_P_BLEED_3 3.06736e-19
C1756 FS_LOW_N DIV_ENABLE 3.50968e-17
C1757 TERM_OR_N_B HS_N_1 3.09551e-17
C1758 FS_N_WELL HS_P 2.924e-15
C1759 PULLUP_N_BLEED_0 TERM_P_R 1.11498e-16
C1760 PULLDOWN_N_R HS_P_3 7.21687e-17
C1761 HS_N_3 PULLUP_P_BLEED_5 5.2499e-17
C1762 DIV_LOW_N HS_N 8.85647e-17
C1763 HS_PBIAS FS_HIGH_N 3.74305e-17
C1764 HS_N_5 PULLDOWN_N_R 6.1589e-17
C1765 HS_N_5 FS_P_BLEED_0 6.1779e-17
C1766 HS_P PULLUP_P_GATE 7.93995e-17
C1767 FS_LOW_N VCM_LOW_OK 7.42025e-17
C1768 HS_P_8 TERM_GATE_P 1.55077e-16
C1769 HS_P_10 HS_P_3 2.86636e-17
C1770 DIV_ENABLE PAD_N 3.38188e-17
C1771 FS_N_BLEED_6 FS_N_BLEED_0 7.62796e-18
C1772 HS_N_1 PULLUP_P_GATE 7.48502e-17
C1773 HS_N_5 HS_P_10 3.08895e-17
C1774 HS_N_3 DIV_P 3.38809e-17
C1775 HS_N_13 DIV_LOW_P 1.02945e-18
C1776 TERM_ENABLE PULLUP_P_BLEED_1 6.06002e-18
C1777 HS_N_11 HS_N_3 6.43885e-17
C1778 PULLUP_N PULLUP_N_BLEED_2 2.26497e-16
C1779 PULLDOWN_N_R PULLUP_N_BLEED_3 7.92848e-17
C1780 FS_LOW_P HS_P_1 1.12624e-16
C1781 HS_PBIAS HS_N_10 1.07528e-15
C1782 HS_N_3 FS_LOW_P 8.50523e-17
C1783 VDD BYPASS_ENABLE 4.51573e-17
C1784 TERM_OR_N_S TERM_GATE_N_BLEED_0 1.78914e-18
C1785 HS_N_4 HS_P_6 5.99014e-17
C1786 FS_N_CONTROL_S FS_N_OUT 4.18743e-17
C1787 HS_N_5 PULLUP_P_BLEED_5 5.2499e-17
C1788 HS_N_9 HS_P_7 4.01009e-17
C1789 HS_N_7 PULLDOWN_N_R 6.83199e-17
C1790 PULLDOWN_N_R TERM_GATE_P 2.62131e-16
C1791 HS_N_7 FS_P_BLEED_0 6.1779e-17
C1792 FS_N_WELL FS_N_BLEED_3 6.10284e-19
C1793 HS_P_10 TERM_GATE_P 1.79029e-16
C1794 HS_N_7 HS_P_10 2.0817e-19
C1795 HS_P_6 HS_P_12 7.01805e-17
C1796 HS_N_11 HS_P_3 2.5076e-17
C1797 HS_N_11 HS_N_5 2.82661e-19
C1798 HS_N_13 HS_N_3 3.08942e-16
C1799 PULLDOWN_N_R PULLUP_N_BLEED_2 7.92848e-17
C1800 FS_LOW_P HS_P_3 4.60724e-17
C1801 PULLUP_N_GATE PULLUP_N_BLEED_3 8.1379e-17
C1802 HS_PBIAS HS_N_12 2.63945e-15
C1803 PULLUP_N_BLEED_1 PULLUP_P 5.74382e-17
C1804 HS_N_5 FS_LOW_P 8.53302e-17
C1805 TERM_OR_N_B TERM_GATE_N_BLEED_0 4.76897e-18
C1806 HS_N_6 HS_P_6 6.9385e-17
C1807 VDD PAD_P 6.48801e-19
C1808 FS_N_WELL FS_N_BLEED_0 3.87093e-16
C1809 PULLUP_N_OUT TERM_P_R 2.62394e-16
C1810 TERM_ENABLE HS_P_9 7.43459e-17
C1811 HS_PBIAS FS_N_OUT 9.49388e-16
C1812 HS_N_7 PULLUP_P_BLEED_5 5.2499e-17
C1813 HS_P DIV_ENABLE 3.81812e-17
C1814 HS_P_7 HS_P_11 9.63e-17
C1815 TERM_P_R TERM_OR_N_NS 1.7892e-16
C1816 TERM_GATE_N PULLDOWN_N_R 1.54013e-16
C1817 PAD_P HS_P_5 1.15443e-15
C1818 HS_N_1 DIV_ENABLE 3.52797e-17
C1819 HS_P_6 HS_P_2 6.95596e-17
C1820 PULLUP_N_OUT FS_HIGH_N 4.37656e-17
C1821 HS_P_9 TERM_OR_P_NS 3.93679e-17
C1822 VCM_LOW_OK HS_P 4.3124e-17
C1823 DIV_P TERM_GATE_P 2.27442e-17
C1824 FS_P_OUT PULLUP_P_OUT 5.75658e-16
C1825 FS_N_GATE PULLUP_P 1.05236e-15
C1826 FS_N_BLEED_6 VDD 4.51172e-16
C1827 HS_N_13 HS_P_3 2.4636e-17
C1828 HS_N_11 TERM_GATE_P 1.08523e-16
C1829 HS_N_1 VCM_LOW_OK 3.48887e-17
C1830 HS_N_13 HS_N_5 1.03866e-16
C1831 HS_N_11 HS_N_7 2.98539e-17
C1832 PULLUP_N TERM_N_R 2.24127e-16
C1833 PULLUP_N_GATE PULLUP_N_BLEED_2 6.88689e-17
C1834 HS_PBIAS HS_N_2 2.89631e-15
C1835 FS_LOW_P TERM_GATE_P 1.53568e-16
C1836 HS_N_7 FS_LOW_P 8.55008e-17
C1837 TERM_ENABLE TERM_OR_P_B 5.36669e-15
C1838 FS_P_WELL PULLUP_P_OUT 3.18557e-15
C1839 HS_N_8 HS_P_6 4.80752e-17
C1840 HS_PBIAS PULLUP_P_CONTROL_S 4.82815e-17
C1841 TERM_OR_N_S VDD 1.35734e-14
C1842 PULLDOWN_N TERM_P_R 7.81167e-16
C1843 TERM_P_R PULLDOWN_P 1.3388e-16
C1844 PAD_P HS_P_4 1.13663e-15
C1845 FS_P_BLEED_1 FS_HIGH_P 5.62196e-19
C1846 TERM_N_R PULLUP_P_BLEED_3 1.14443e-16
C1847 PULLDOWN_N_R PULLUP_P_BLEED_6 9.19551e-17
C1848 PULLUP_P PULLDOWN_P_R 6.95504e-19
C1849 TERM_OR_P_B TERM_OR_P_NS 3.40561e-15
C1850 DIV_N PULLDOWN_N_R 4.20197e-17
C1851 PULLUP_P_BLEED_0 PULLUP_P_GATE 5.11673e-17
C1852 FS_HIGH_N PULLDOWN_P 3.74305e-17
C1853 PULLUP_N_BLEED_2 FS_LOW_P 5.87202e-17
C1854 TERM_P_R PULLUP_P_BLEED_2 4.58761e-17
C1855 HS_P_9 PAD_N 6.47937e-15
C1856 FS_P_OUT FS_P_BLEED_3 3.14506e-19
C1857 HS_P_1 HS_P_3 6.15392e-17
C1858 DIV_LOW_P TERM_GATE_P 4.27971e-18
C1859 HS_N_5 HS_P_1 3.09658e-17
C1860 HS_N_3 HS_P_3 3.7333e-17
C1861 HS_N_13 TERM_GATE_P 1.076e-16
C1862 HS_N_3 HS_N_5 2.0615e-18
C1863 HS_N_9 TERM_P_R 5.92021e-17
C1864 PULLDOWN_N_R TERM_N_R 2.22554e-16
C1865 HS_N_13 HS_N_7 9.54629e-17
C1866 HS_N_11 TERM_GATE_N 4.85582e-17
C1867 HS_PBIAS HS_N_4 1.07268e-15
C1868 TERM_N_R FS_P_BLEED_0 5.72918e-17
C1869 TERM_GATE_N FS_LOW_P 4.93931e-17
C1870 TERM_VCM HS_P_6 9.61503e-17
C1871 FS_P_BLEED_1 PULLDOWN_P_R 1.01235e-16
C1872 FS_P_BLEED_2 PULLDOWN_N_R 5.44487e-17
C1873 TERM_OR_N_B VDD 1.41259e-14
C1874 FS_P_WELL FS_P_BLEED_3 6.01861e-18
C1875 PULLUP_N_OUT HS_N_12 1.36783e-17
C1876 PULLUP_P_BLEED_5 PULLUP_P_BLEED_6 4.72363e-15
C1877 FS_P_BLEED_2 FS_P_BLEED_0 8.54567e-18
C1878 TERM_N_R HS_P_10 5.03697e-17
C1879 FS_N_BLEED_0 DIV_ENABLE 2.67272e-19
C1880 FS_N_WELL VDD 1.36455e-13
C1881 DIV_N PULLUP_P_BLEED_5 6.00678e-19
C1882 DIV_LOW_N PULLDOWN_N_R 8.86788e-17
C1883 FS_P_GATE PULLUP_P_GATE 5.69672e-17
C1884 PULLUP_N_OUT FS_N_OUT 5.13997e-16
C1885 TERM_GATE_N_BLEED_0 VCM_LOW_OK 8.40177e-17
C1886 VDD PULLUP_P_GATE 1.65757e-14
C1887 HS_PBIAS HS_P_12 4.10448e-15
C1888 HS_N_11 PULLUP_P_BLEED_6 2.43374e-17
C1889 HS_P_1 TERM_GATE_P 2.54341e-16
C1890 HS_N_5 HS_P_3 3.08895e-17
C1891 HS_N_7 HS_P_1 2.82661e-19
C1892 HS_N FS_P_BLEED_1 8.04284e-17
C1893 HS_N_3 TERM_GATE_P 1.11035e-16
C1894 DIV_N DIV_P 4.86079e-14
C1895 HS_P_0 PULLDOWN_P_R 3.03728e-17
C1896 HS_N_13 TERM_GATE_N 4.80752e-17
C1897 HS_N_11 DIV_N 3.31088e-17
C1898 HS_N_3 HS_N_7 2.87722e-17
C1899 HS_N_9 HS_N_10 4.45695e-17
C1900 PULLUP_N_WELL FS_N_BLEED_5 6.74983e-19
C1901 PULLUP_N_GATE TERM_N_R 1.68546e-16
C1902 HS_PBIAS HS_N_6 4.87661e-15
C1903 DIV_N FS_LOW_P 6.00722e-15
C1904 TERM_P_R HS_P_11 1.48523e-16
C1905 HS_N_12 PULLDOWN_P 5.19379e-17
C1906 HS_N_10 FS_P_CONTROL_S 3.2364e-17
C1907 HS_P HS_P_9 6.36218e-15
C1908 PULLUP_N_OUT PULLUP_P_CONTROL_S 5.46167e-17
C1909 HS_N_11 TERM_N_R 5.99647e-17
C1910 HS_PBIAS HS_P_2 3.95109e-15
C1911 TERM_VCM PULLUP_N_WELL 3.05856e-16
C1912 HS_N_11 FS_P_BLEED_2 3.47206e-17
C1913 FS_N_OUT PULLDOWN_P 6.14403e-16
C1914 TERM_N_R FS_LOW_P 2.27359e-16
C1915 HS_N HS_P_0 5.49057e-16
C1916 HS_N_0 PAD_P 1.45583e-16
C1917 FS_P_BLEED_2 FS_LOW_P 7.13946e-17
C1918 TERM_P_R PULLUP_P_BLEED_4 4.76598e-17
C1919 HS_N_13 PULLUP_P_BLEED_6 2.40376e-17
C1920 FS_N_CONTROL_S TERM_VCM 4.23029e-17
C1921 HS_P_3 TERM_GATE_P 1.56594e-16
C1922 HS_N_3 TERM_GATE_N 4.80752e-17
C1923 HS_N_13 DIV_N 3.31088e-17
C1924 HS_N_11 DIV_LOW_N 6.1779e-17
C1925 HS_N_5 HS_N_7 7.79839e-17
C1926 TERM_P_R TERM_GATE_P_BLEED_1 2.57363e-18
C1927 DIV_N DIV_LOW_P 8.93453e-16
C1928 HS_N_5 TERM_GATE_P 1.15021e-16
C1929 HS_N_9 HS_N_12 3.48887e-17
C1930 PULLUP_N_BLEED_6 TERM_N_R 5.72918e-17
C1931 HS_PBIAS HS_N_8 9.64282e-15
C1932 DIV_LOW_N FS_LOW_P 8.85647e-17
C1933 HS_P TERM_OR_P_B 9.16953e-17
C1934 HS_N_10 HS_P_11 3.50619e-18
C1935 PULLUP_N_OUT HS_N_4 2.97726e-18
C1936 HS_N_1 TERM_OR_P_B 7.4383e-17
C1937 HS_N_12 FS_P_CONTROL_S 3.22599e-17
C1938 HS_N_9 FS_N_OUT 6.16744e-17
C1939 FS_N_BLEED_2 FS_HIGH_N 2.82661e-19
C1940 HS_PBIAS FS_N_BLEED_5 8.85647e-17
C1941 BYPASS_ENABLE RX_P 4.9179e-15
C1942 HS_PBIAS PULLUP_P_WELL 5.89791e-16
C1943 FS_P_GATE DIV_ENABLE 4.24205e-18
C1944 HS_N_13 TERM_N_R 5.95247e-17
C1945 VDD DIV_ENABLE 1.46286e-16
C1946 DIFF_ENABLE TERM_P_R 2.11502e-15
C1947 HS_N_13 FS_P_BLEED_2 3.47206e-17
C1948 HS_N_0 TERM_OR_N_S 6.38433e-17
C1949 FS_N_OUT FS_P_CONTROL_S 6.62605e-18
C1950 FS_P_GATE VCM_LOW_OK 1.26536e-15
C1951 HS_N_10 PULLUP_P_BLEED_4 3.48887e-17
C1952 HS_N_3 PULLUP_P_BLEED_6 2.79501e-17
C1953 FS_P_OUT FS_HIGH_P 1.12244e-16
C1954 DIV_ENABLE HS_P_5 2.52105e-18
C1955 PULLUP_P_BLEED_0 PULLUP_P_BLEED_1 1.16396e-15
C1956 VDD VCM_LOW_OK 5.76721e-14
C1957 DIFF_ENABLE FS_HIGH_N 2.58323e-16
C1958 HS_N_7 TERM_GATE_P 1.21977e-16
C1959 HS_N_13 DIV_LOW_N 6.1779e-17
C1960 HS_N_9 HS_N_2 2.0817e-19
C1961 HS_N_3 DIV_N 3.35398e-17
C1962 PULLUP_N_OUT HS_P_12 3.00582e-17
C1963 HS_N_5 TERM_GATE_N 5.06069e-17
C1964 PAD_P BYPASS_ENABLE 8.22842e-15
C1965 PULLUP_N_BLEED_3 PULLUP_N_BLEED_2 3.56186e-15
C1966 HS_PBIAS TERM_VCM 8.64504e-16
C1967 HS_N_12 HS_P_11 1.1035e-16
C1968 VCM_LOW_OK HS_P_5 3.48887e-17
C1969 HS_N_9 PULLUP_P_CONTROL_S 3.48887e-17
C1970 FS_P_WELL FS_HIGH_P 1.22539e-15
C1971 TERM_ENABLE HS_P_6 2.40376e-17
C1972 PULLUP_N_OUT HS_N_6 4.91368e-17
C1973 PULLUP_N_BLEED_0 TERM_VCM 1.34592e-16
C1974 HS_N_2 FS_P_CONTROL_S 3.22599e-17
C1975 FS_N_BLEED_1 FS_HIGH_N 4.04393e-19
C1976 TERM_P_R PULLUP_P_OUT 3.04893e-16
C1977 HS_N_3 TERM_N_R 5.89263e-17
C1978 PAD_P RX_P 8.52003e-15
C1979 HS_P_6 TERM_OR_P_NS 2.84614e-17
C1980 HS_N_3 FS_P_BLEED_2 3.47206e-17
C1981 PULLUP_P_BLEED_3 PULLUP_P 1.03866e-16
C1982 HS_N_0 TERM_OR_N_B 3.20569e-17
C1983 FS_N_BLEED_6 BYPASS_ENABLE 7.65665e-18
C1984 PULLUP_N_OUT HS_P_2 7.96444e-17
C1985 FS_P_OUT PULLDOWN_P_R 7.56607e-16
C1986 TERM_GATE_P_BLEED_2 VCM_LOW_OK 1.42923e-17
C1987 HS_N_12 PULLUP_P_BLEED_4 3.48887e-17
C1988 HS_N_5 PULLUP_P_BLEED_6 3.06896e-17
C1989 VCM_LOW_OK HS_P_4 6.67267e-17
C1990 HS_N_5 DIV_N 3.31088e-17
C1991 HS_N_3 DIV_LOW_N 6.1779e-17
C1992 HS_N_7 TERM_GATE_N 5.24193e-17
C1993 HS_N_9 HS_N_4 3.26173e-17
C1994 VDD PULLUP_P_BLEED_1 3.71e-18
C1995 HS_P_0 HS_P_13 1.89914e-17
C1996 FS_P_WELL PULLDOWN_P_R 3.3755e-15
C1997 HS_N_2 HS_P_11 3.08895e-17
C1998 FS_N_OUT PULLUP_P_BLEED_4 6.16744e-17
C1999 HS_N_0 PULLUP_P_GATE 7.59445e-17
C2000 PULLDOWN_N_R PULLUP_P 5.76752e-17
C2001 HS_N_6 PULLDOWN_P 4.42824e-17
C2002 PULLUP_N_OUT HS_N_8 6.1286e-17
C2003 TERM_N_R HS_P_3 5.03697e-17
C2004 HS_N_4 FS_P_CONTROL_S 3.22599e-17
C2005 HS_N_5 TERM_N_R 5.89263e-17
C2006 HS_N_10 PULLUP_P_OUT 2.54545e-17
C2007 FS_P_OUT HS_N 2.04712e-14
C2008 PULLUP_P_OUT TERM_OR_P_S 4.40679e-18
C2009 PULLUP_N_OUT PULLUP_P_WELL 6.00477e-16
C2010 TERM_ENABLE PULLUP_N_WELL 5.48453e-16
C2011 HS_N_9 HS_P_12 6.57781e-17
C2012 HS_N_5 FS_P_BLEED_2 3.47206e-17
C2013 PULLUP_N_OUT FS_N_BLEED_5 1.01235e-16
C2014 HS_P_6 PAD_N 3.12636e-16
C2015 HS_N FS_P_WELL 4.10033e-14
C2016 HS_N_2 PULLUP_P_BLEED_4 3.48887e-17
C2017 HS_N_7 PULLUP_P_BLEED_6 3.66315e-17
C2018 FS_N_CONTROL_S TERM_ENABLE 7.64375e-17
C2019 DIV_N TERM_GATE_P 1.77929e-18
C2020 PULLDOWN_N_R FS_P_BLEED_1 1.01235e-16
C2021 HS_N_7 DIV_N 3.31088e-17
C2022 HS_N_5 DIV_LOW_N 6.1779e-17
C2023 HS_N_9 HS_N_6 4.10107e-17
C2024 PULLUP_N_WELL FS_N_BLEED_4 6.74983e-19
C2025 HS_PBIAS TERM_GATE_N_BLEED_2 7.92848e-17
C2026 PULLUP_P_BLEED_5 PULLUP_P 1.5607e-16
C2027 HS_N_4 HS_P_11 6.60582e-17
C2028 FS_P_BLEED_0 FS_P_BLEED_1 7.1724e-15
C2029 PULLUP_N_GATE PULLUP_P 1.41779e-15
C2030 FS_N_WELL BYPASS_ENABLE 6.52469e-17
C2031 HS_N_8 PULLDOWN_P 4.42824e-17
C2032 TERM_GATE_P_BLEED_0 HS_P_9 3.88758e-17
C2033 PULLUP_N_OUT TERM_VCM 5.07356e-16
C2034 HS_N_9 HS_P_2 3.08895e-17
C2035 TERM_N_R TERM_GATE_P 1.39719e-15
C2036 HS_N_6 FS_P_CONTROL_S 3.22599e-17
C2037 FS_N_BLEED_1 FS_N_OUT 1.30789e-20
C2038 HS_N_12 PULLUP_P_OUT 2.4816e-17
C2039 TERM_VCM TERM_OR_N_NS 5.97661e-17
C2040 HS_N_10 FS_P_BLEED_3 1.96739e-19
C2041 HS_N_7 TERM_N_R 1.09296e-16
C2042 VDD HS_P_9 6.03255e-15
C2043 HS_PBIAS TERM_GATE_N_BLEED_1 4.82815e-17
C2044 FS_LOW_N PULLUP_N_WELL 1.37627e-16
C2045 HS_N_7 FS_P_BLEED_2 3.47206e-17
C2046 FS_N_BLEED_5 PULLDOWN_P 8.85647e-17
C2047 PULLDOWN_N_R HS_P_0 3.03728e-17
C2048 HS_P_7 PULLDOWN_P_R 2.41139e-17
C2049 HS_N_4 PULLUP_P_BLEED_4 3.48887e-17
C2050 HS_P_5 HS_P_9 6.21526e-19
C2051 HS_P_12 HS_P_11 4.69655e-14
C2052 HS_N_0 DIV_ENABLE 1.72358e-15
C2053 HS_N_7 DIV_LOW_N 6.1779e-17
C2054 TERM_GATE_N DIV_N 1.70326e-17
C2055 HS_N_9 HS_N_8 1.18342e-13
C2056 PULLUP_P_WELL PULLUP_P_BLEED_2 1.20134e-16
C2057 TERM_GATE_P_BLEED_0 TERM_OR_P_B 4.79522e-18
C2058 HS_P_0 HS_P_10 2.2381e-15
C2059 HS_PBIAS TERM_ENABLE 7.33359e-16
C2060 HS_N_6 HS_P_11 3.08895e-17
C2061 PULLUP_N_BLEED_6 PULLUP_P 1.07214e-16
C2062 VDD TERM_OR_P_B 1.60198e-14
C2063 HS_N_0 VCM_LOW_OK 3.48887e-17
C2064 PULLUP_N_BLEED_0 TERM_ENABLE 1.1535e-16
C2065 PULLDOWN_N TERM_VCM 4.2801e-17
C2066 TERM_VCM PULLDOWN_P 1.85479e-16
C2067 HS_P_6 HS_P 3.46603e-15
C2068 HS_N_9 PULLUP_P_WELL 2.12663e-16
C2069 HS_PBIAS FS_N_BLEED_4 8.85647e-17
C2070 HS_N_8 FS_P_CONTROL_S 3.23809e-17
C2071 HS_P_7 HS_N 1.51318e-16
C2072 HS_N_11 FS_P_BLEED_1 6.1779e-17
C2073 HS_N_10 FS_P_BLEED_5 6.1779e-17
C2074 HS_N_1 HS_P_6 6.02318e-17
C2075 HS_N_2 PULLUP_P_OUT 2.45088e-17
C2076 TERM_GATE_N TERM_N_R 2.76669e-14
C2077 HS_N_12 FS_P_BLEED_3 1.32245e-19
C2078 HS_P_11 HS_P_2 1.05682e-18
C2079 HS_P_9 HS_P_4 4.19982e-17
C2080 HS_P_5 TERM_OR_P_B 1.01557e-16
C2081 HS_N_13 PULLUP_P 4.37656e-17
C2082 PULLUP_P_CONTROL_S PULLUP_P_OUT 1.1774e-17
C2083 TERM_VCM PULLUP_P_BLEED_2 1.88161e-17
C2084 HS_N_6 PULLUP_P_BLEED_4 3.48887e-17
C2085 FS_N_OUT FS_P_BLEED_3 1.39258e-16
C2086 FS_P_OUT HS_P_13 1.27518e-16
C2087 HS_PBIAS PULLUP_N_BLEED_4 1.6332e-17
C2088 HS_N_9 TERM_VCM 1.48755e-16
C2089 FS_N_BLEED_6 FS_N_WELL 6.3693e-18
C2090 TERM_GATE_N DIV_LOW_N 2.98455e-17
C2091 TERM_P_R PULLUP_N_BLEED_1 4.76598e-17
C2092 TERM_GATE_P_BLEED_2 TERM_OR_P_B 3.48832e-18
C2093 HS_PBIAS FS_LOW_N 3.49326e-16
C2094 HS_N_8 HS_P_11 2.85655e-17
C2095 TERM_OR_N_S TERM_OR_N_B 5.00768e-15
C2096 HS_N_11 HS_P_0 4.3885e-17
C2097 FS_P_WELL HS_P_13 2.21209e-16
C2098 DIV_ENABLE BYPASS_ENABLE 7.45289e-14
C2099 PULLUP_N_OUT TERM_GATE_N_BLEED_2 9.19551e-17
C2100 HS_P_4 TERM_OR_P_B 1.0189e-16
C2101 HS_P_0 FS_LOW_P 9.31951e-17
C2102 FS_HIGH_N PULLUP_N_BLEED_1 1.66028e-16
C2103 HS_N_13 FS_P_BLEED_1 6.1779e-17
C2104 HS_N_12 FS_P_BLEED_5 6.1779e-17
C2105 HS_N_10 FS_P_BLEED_6 6.1779e-17
C2106 HS_N_4 PULLUP_P_OUT 2.40376e-17
C2107 TERM_P_R FS_HIGH_P 1.00821e-17
C2108 DIV_N TERM_N_R 1.97875e-16
C2109 PULLUP_N_WELL HS_P 2.91946e-16
C2110 DIV_N FS_P_BLEED_2 1.0151e-16
C2111 FS_N_OUT FS_P_BLEED_5 5.62374e-17
C2112 HS_N_8 PULLUP_P_BLEED_4 3.48887e-17
C2113 FS_HIGH_N FS_HIGH_P 3.05739e-14
C2114 DIV_ENABLE RX_P 8.82991e-16
C2115 FS_N_GATE TERM_P_R 8.04253e-16
C2116 PULLUP_N_OUT TERM_GATE_N_BLEED_1 5.46167e-17
C2117 FS_N_CONTROL_S HS_P 9.19309e-17
C2118 DIV_N DIV_LOW_N 5.26099e-15
C2119 PULLUP_N_BLEED_5 PULLDOWN_P 3.19536e-18
C2120 FS_N_GATE FS_HIGH_N 5.97523e-15
C2121 PULLUP_P_WELL PULLUP_P_BLEED_4 2.57363e-18
C2122 FS_P_BLEED_2 TERM_N_R 6.10527e-17
C2123 TERM_VCM HS_P_11 1.3824e-16
C2124 PULLDOWN_N PULLUP_N_BLEED_5 7.80014e-18
C2125 TERM_GATE_N_BLEED_2 PULLDOWN_P 7.92848e-17
C2126 PULLUP_N_OUT TERM_ENABLE 1.92431e-16
C2127 HS_N_3 FS_P_BLEED_1 6.1779e-17
C2128 TERM_P_R PULLDOWN_P_R 1.63221e-16
C2129 PAD_P DIV_ENABLE 1.46818e-16
C2130 FS_N_BLEED_2 FS_N_BLEED_5 1.05588e-16
C2131 HS_N_2 FS_P_BLEED_5 6.1779e-17
C2132 HS_N_12 FS_P_BLEED_6 6.1779e-17
C2133 HS_N_6 PULLUP_P_OUT 2.40376e-17
C2134 FS_P_OUT PULLDOWN_N_R 6.89858e-16
C2135 DIV_LOW_N TERM_N_R 3.0544e-16
C2136 HS_N_10 FS_HIGH_P 3.83793e-19
C2137 PULLUP_N_OUT FS_N_BLEED_4 1.01235e-16
C2138 HS_N_5 PULLUP_P 6.95504e-19
C2139 HS_N_10 FS_N_GATE 2.12997e-17
C2140 PULLUP_N_OUT TERM_OR_P_NS 1.1021e-16
C2141 FS_N_OUT FS_P_BLEED_6 4.87706e-17
C2142 TERM_VCM PULLUP_P_BLEED_4 3.47206e-17
C2143 TERM_GATE_N_BLEED_1 PULLDOWN_P 4.82815e-17
C2144 HS_P_7 HS_P_13 1.42039e-16
C2145 PULLDOWN_N_R FS_P_WELL 2.76564e-15
C2146 VCM_LOW_OK PAD_P 4.75972e-18
C2147 HS_P_2 PULLUP_P_OUT 6.77322e-17
C2148 FS_P_WELL FS_P_BLEED_0 4.87941e-15
C2149 HS_N_9 TERM_GATE_N_BLEED_2 5.2499e-17
C2150 PULLUP_N_WELL FS_N_BLEED_3 6.74983e-19
C2151 TERM_P_R HS_N 2.89261e-16
C2152 DIV_P RX_N 3.75991e-16
C2153 FS_N_BLEED_6 DIV_ENABLE 3.56355e-17
C2154 HS_PBIAS HS_P 1.6547e-13
C2155 HS_P_0 HS_P_1 3.64066e-14
C2156 PULLUP_N_BLEED_3 PULLUP_P 1.52593e-19
C2157 TERM_ENABLE PULLDOWN_P 3.74305e-17
C2158 HS_PBIAS HS_N_1 9.60149e-15
C2159 PULLUP_N_OUT FS_LOW_N 6.42575e-17
C2160 FS_HIGH_N HS_N 5.08233e-17
C2161 PULLDOWN_N TERM_ENABLE 6.10321e-17
C2162 HS_N_10 PULLDOWN_P_R 2.43619e-17
C2163 HS_N_5 FS_P_BLEED_1 6.1779e-17
C2164 HS_N_4 FS_P_BLEED_5 6.1779e-17
C2165 HS_N_2 FS_P_BLEED_6 6.1779e-17
C2166 HS_N_8 PULLUP_P_OUT 2.40376e-17
C2167 FS_N_BLEED_1 FS_N_BLEED_5 1.05416e-16
C2168 FS_LOW_N TERM_OR_N_NS 7.06477e-16
C2169 HS_N_12 FS_HIGH_P 2.44156e-19
C2170 HS_N_9 TERM_GATE_N_BLEED_1 3.48887e-17
C2171 PULLUP_N_WELL FS_N_BLEED_0 6.74983e-19
C2172 HS_N_7 PULLUP_P 5.06175e-17
C2173 FS_N_BLEED_4 PULLDOWN_P 8.85647e-17
C2174 TERM_ENABLE PULLUP_P_BLEED_2 8.22106e-17
C2175 HS_N_0 TERM_OR_P_B 7.49662e-17
C2176 HS_N_12 FS_N_GATE 2.56664e-17
C2177 PULLUP_N_OUT PAD_N 1.29226e-15
C2178 FS_N_OUT FS_HIGH_P 9.98305e-17
C2179 PULLUP_P_WELL PULLUP_P_OUT 3.20469e-14
C2180 TERM_OR_N_S VCM_LOW_OK 4.63203e-15
C2181 HS_P_7 HS_P_8 3.09838e-14
C2182 FS_P_OUT DIV_P 1.27896e-17
C2183 HS_N_11 FS_P_OUT 4.39756e-16
C2184 HS_N_9 TERM_ENABLE 4.80752e-17
C2185 HS_N_10 HS_N 3.84913e-15
C2186 HS_P_0 HS_P_3 3.77193e-17
C2187 FS_P_OUT FS_LOW_P 5.67106e-16
C2188 PULLUP_N_BLEED_4 PULLDOWN_P 8.01443e-17
C2189 FS_N_GATE FS_N_OUT 1.51029e-13
C2190 TERM_GATE_P_BLEED_0 HS_P_6 2.40376e-17
C2191 HS_N_5 HS_P_0 3.73287e-17
C2192 PULLDOWN_N PULLUP_N_BLEED_4 7.62796e-18
C2193 HS_N_11 FS_P_WELL 2.00581e-15
C2194 HS_N_12 PULLDOWN_P_R 2.42376e-17
C2195 FS_LOW_N PULLDOWN_P 8.21471e-17
C2196 HS_N_7 FS_P_BLEED_1 6.1779e-17
C2197 HS_PBIAS FS_N_BLEED_3 8.85647e-17
C2198 HS_N_9 TERM_OR_P_NS 1.00158e-17
C2199 PULLUP_N_CONTROL_S HS_P 3.22793e-17
C2200 FS_P_WELL FS_LOW_P 2.24754e-15
C2201 VDD HS_P_6 6.83004e-15
C2202 PULLDOWN_N_R HS_P_7 2.41789e-17
C2203 HS_N_4 FS_P_BLEED_6 6.1779e-17
C2204 HS_N_2 FS_HIGH_P 1.12441e-17
C2205 TERM_VCM PULLUP_P_OUT 3.97279e-16
C2206 HS_N_6 FS_P_BLEED_5 6.23109e-17
C2207 FS_N_WELL DIV_ENABLE 2.67471e-16
C2208 HS_P_6 HS_P_5 3.23343e-14
C2209 PULLUP_P_CONTROL_S FS_HIGH_P 9.40947e-18
C2210 TERM_GATE_N PULLUP_P 2.62957e-16
C2211 TERM_OR_N_B VCM_LOW_OK 4.35333e-15
C2212 PULLUP_P_WELL FS_P_BLEED_3 6.74983e-19
C2213 FS_P_OUT DIV_LOW_P 1.36053e-16
C2214 HS_P_7 HS_P_10 1.06868e-16
C2215 DIV_ENABLE PULLUP_P_GATE 6.06007e-19
C2216 HS_N_13 FS_P_OUT 5.28248e-16
C2217 HS_N_9 FS_LOW_N 8.74721e-17
C2218 HS_N_12 HS_N 8.83112e-15
C2219 HS_N_7 HS_P_0 4.04393e-19
C2220 TERM_ENABLE HS_P_11 7.92264e-17
C2221 HS_P_0 TERM_GATE_P 2.58368e-16
C2222 HS_N_13 FS_P_WELL 1.9566e-15
C2223 VCM_LOW_OK PULLUP_P_GATE 3.49387e-16
C2224 HS_N_2 PULLDOWN_P_R 2.40376e-17
C2225 FS_N_OUT HS_N 1.24111e-15
C2226 PULLUP_N_OUT HS_P 9.36445e-17
C2227 HS_P_6 HS_P_4 6.95596e-17
C2228 HS_N_6 FS_P_BLEED_6 6.1779e-17
C2229 PAD_P HS_P_9 1.35439e-15
C2230 HS_N_9 PAD_N 1.0992e-15
C2231 HS_N_8 FS_P_BLEED_5 6.26589e-17
C2232 PULLUP_P_CONTROL_S PULLDOWN_P_R 5.46167e-17
C2233 PULLUP_N_OUT HS_N_1 5.06175e-17
C2234 TERM_P_R HS_P_13 8.55358e-17
C2235 HS_N_10 FS_P_BLEED_4 2.91546e-17
C2236 PULLUP_P PULLUP_P_BLEED_6 1.46943e-16
C2237 HS_P_11 TERM_OR_P_NS 4.28516e-17
C2238 PULLUP_N_WELL VDD 2.26686e-14
C2239 TERM_ENABLE PULLUP_P_BLEED_4 6.02823e-17
C2240 PULLUP_P_WELL FS_P_BLEED_5 6.74983e-19
C2241 TERM_ENABLE TERM_GATE_P_BLEED_1 1.03191e-16
C2242 HS_N_3 FS_P_OUT 4.87923e-16
C2243 HS_N_2 HS_N 6.79185e-15
C2244 FS_N_CONTROL_S VDD 7.07839e-16
C2245 HS_PBIAS PULLUP_P_BLEED_0 1.39678e-17
C2246 HS_P_7 FS_LOW_P 4.566e-17
C2247 PULLUP_N TERM_P_R 1.81265e-16
C2248 TERM_N_R PULLUP_P 5.05824e-16
C2249 HS_N PULLUP_P_CONTROL_S 4.82815e-17
C2250 HS_N_3 FS_P_WELL 1.91956e-15
C2251 HS_N_4 PULLDOWN_P_R 2.40376e-17
C2252 FS_N_BLEED_2 FS_N_BLEED_4 1.23091e-16
C2253 PULLUP_P_BLEED_1 PULLUP_P_GATE 1.20989e-16
C2254 HS_N_8 FS_P_BLEED_6 6.1779e-17
C2255 HS_N_10 HS_P_13 2.51995e-17
C2256 TERM_P_R PULLUP_P_BLEED_3 1.11411e-16
C2257 HS_N_12 FS_P_BLEED_4 2.88761e-17
C2258 TERM_P_R HS_P_8 8.29638e-17
C2259 HS_N_1 PULLDOWN_P 4.42824e-17
C2260 HS_P_11 PAD_N 1.42473e-15
C2261 TERM_ENABLE DIFF_ENABLE 3.35499e-17
C2262 DIV_LOW_N PULLUP_P 4.81895e-17
C2263 PULLUP_N_OUT FS_N_BLEED_3 5.21642e-17
C2264 PULLUP_P_WELL FS_P_BLEED_6 3.05394e-17
C2265 FS_P_BLEED_4 FS_N_OUT 6.63891e-17
C2266 FS_P_OUT HS_P_3 9.14815e-17
C2267 FS_LOW_N PULLUP_P_BLEED_4 2.19908e-17
C2268 HS_N_5 FS_P_OUT 4.33306e-16
C2269 TERM_N_R FS_P_BLEED_1 1.14443e-16
C2270 HS_P_12 PULLDOWN_P_R 2.40376e-17
C2271 HS_N_4 HS_N 1.43714e-15
C2272 FS_N_BLEED_2 FS_LOW_N 6.21526e-19
C2273 HS_N_9 HS_P 1.20311e-13
C2274 HS_PBIAS FS_P_GATE 1.89121e-15
C2275 PULLDOWN_N_R TERM_P_R 1.78924e-16
C2276 HS_PBIAS VDD 8.36929e-14
C2277 FS_P_BLEED_2 FS_P_BLEED_1 8.68609e-15
C2278 HS_N_9 HS_N_1 4.2943e-17
C2279 TERM_P_R FS_P_BLEED_0 4.59561e-17
C2280 HS_N_5 FS_P_WELL 1.93199e-15
C2281 HS_N_6 PULLDOWN_P_R 2.40376e-17
C2282 PULLDOWN_N_R FS_HIGH_N 3.74305e-17
C2283 HS_P FS_P_CONTROL_S 3.24645e-17
C2284 HS_N_12 HS_P_13 2.46514e-17
C2285 FS_N_BLEED_1 FS_N_BLEED_4 1.22362e-16
C2286 TERM_ENABLE PULLUP_P_OUT 1.15152e-14
C2287 PULLUP_N_BLEED_0 VDD 7.77842e-16
C2288 HS_N_2 FS_P_BLEED_4 2.84614e-17
C2289 TERM_P_R HS_P_10 1.42295e-16
C2290 HS_PBIAS HS_P_5 3.80328e-15
C2291 FS_LOW_N DIFF_ENABLE 2.52569e-16
C2292 HS_N_1 FS_P_CONTROL_S 3.24013e-17
C2293 FS_N_BLEED_3 PULLDOWN_P 9.71242e-17
C2294 HS_P_2 PULLDOWN_P_R 7.46551e-17
C2295 HS_N_8 FS_N_GATE 6.84656e-20
C2296 HS_N HS_P_12 5.56696e-16
C2297 FS_N_BLEED_5 FS_HIGH_P 1.52593e-19
C2298 HS_N_0 HS_P_6 6.11393e-17
C2299 PULLUP_P_WELL FS_HIGH_P 2.75853e-16
C2300 PULLUP_P_OUT TERM_OR_P_NS 1.01098e-16
C2301 HS_P_7 HS_P_1 5.97018e-17
C2302 FS_P_OUT TERM_GATE_P 2.28139e-16
C2303 HS_N_7 FS_P_OUT 5.24787e-16
C2304 PULLDOWN_N_R HS_N_10 2.40376e-17
C2305 FS_N_BLEED_1 FS_LOW_N 1.05682e-18
C2306 TERM_VCM PULLUP_N_BLEED_1 4.26329e-17
C2307 HS_N_6 HS_N 7.99416e-15
C2308 FS_N_GATE FS_N_BLEED_5 2.50046e-16
C2309 PULLUP_N_GATE TERM_P_R 1.79634e-16
C2310 HS_N_10 FS_P_BLEED_0 6.1779e-17
C2311 HS_P HS_P_11 5.65023e-15
C2312 HS_N_7 FS_P_WELL 1.952e-15
C2313 HS_PBIAS HS_P_4 8.54683e-15
C2314 HS_N_8 PULLDOWN_P_R 2.40376e-17
C2315 PULLUP_N_OUT PULLUP_P_BLEED_0 9.26796e-17
C2316 HS_N_1 HS_P_11 2.84614e-17
C2317 PULLUP_N_GATE FS_HIGH_N 2.61883e-18
C2318 PULLUP_N_CONTROL_S VDD 4.51558e-16
C2319 TERM_P_R DIV_P 2.24156e-17
C2320 HS_N_4 FS_P_BLEED_4 3.2583e-17
C2321 HS_N_10 HS_P_10 9.28844e-17
C2322 HS_N_2 HS_P_13 7.76185e-17
C2323 TERM_VCM FS_HIGH_P 1.35668e-16
C2324 HS_N HS_P_2 4.63517e-16
C2325 HS_N_11 TERM_P_R 5.99647e-17
C2326 PULLUP_P_WELL PULLDOWN_P_R 5.4541e-16
C2327 TERM_P_R FS_LOW_P 2.50187e-16
C2328 TERM_VCM FS_N_GATE 1.09313e-15
C2329 HS_P PULLUP_P_BLEED_4 3.48887e-17
C2330 HS_P_7 HS_P_3 6.11551e-17
C2331 PULLUP_P_OUT PAD_N 2.02005e-16
C2332 HS_N_1 PULLUP_P_BLEED_4 3.48887e-17
C2333 HS_N_8 HS_N 2.60585e-15
C2334 HS_N_10 PULLUP_P_BLEED_5 5.26957e-17
C2335 FS_HIGH_N FS_LOW_P 5.90964e-17
C2336 PULLDOWN_N_R HS_N_12 6.1589e-17
C2337 DIV_N RX_N 1.36638e-15
C2338 FS_N_BLEED_2 HS_P 9.01557e-17
C2339 PULLUP_N_BLEED_6 TERM_P_R 4.60595e-17
C2340 HS_N_12 FS_P_BLEED_0 6.1779e-17
C2341 PULLUP_N_OUT TERM_GATE_P_BLEED_0 1.06795e-16
C2342 FS_N_BLEED_5 HS_N 1.1535e-16
C2343 TERM_VCM PULLDOWN_P_R 2.23283e-16
C2344 PULLUP_P_WELL HS_N 4.25706e-16
C2345 PULLUP_N_OUT FS_P_GATE 1.26827e-15
C2346 PULLDOWN_N_R FS_N_OUT 6.08223e-16
C2347 HS_N_4 HS_P_13 2.95679e-17
C2348 HS_N_12 HS_P_10 4.37115e-17
C2349 PULLUP_N_OUT VDD 5.36442e-15
C2350 TERM_P_R DIV_LOW_P 1.06371e-18
C2351 HS_N_11 HS_N_10 1.37015e-13
C2352 HS_N_6 FS_P_BLEED_4 3.58482e-17
C2353 FS_N_OUT FS_P_BLEED_0 2.84794e-16
C2354 VDD TERM_OR_N_NS 3.0741e-16
C2355 HS_N_13 TERM_P_R 5.95247e-17
C2356 DIFF_ENABLE HS_P 1.65095e-16
C2357 HS_N_10 FS_LOW_P 8.50523e-17
C2358 PULLUP_N_OUT HS_P_5 2.85937e-17
C2359 FS_LOW_P TERM_OR_P_S 3.65441e-16
C2360 PULLUP_N_BLEED_5 PULLUP_N_BLEED_1 4.49448e-18
C2361 HS_N_7 HS_P_7 2.55858e-19
C2362 HS_P_7 TERM_GATE_P 1.55077e-16
C2363 DIV_N FS_P_OUT 6.9541e-17
C2364 HS_N_12 PULLUP_P_BLEED_5 5.26312e-17
C2365 HS_N_9 PULLUP_P_BLEED_0 1.05304e-18
C2366 PULLDOWN_N_R HS_N_2 2.40376e-17
C2367 VCM_LOW_OK HS_P_9 4.57952e-17
C2368 TERM_VCM HS_N 2.11606e-16
C2369 FS_N_BLEED_1 HS_P 9.67912e-17
C2370 HS_N_2 FS_P_BLEED_0 6.1779e-17
C2371 HS_P_12 HS_P_13 4.70352e-14
C2372 PULLDOWN_N_R PULLUP_P_CONTROL_S 5.46167e-17
C2373 DIV_N FS_P_WELL 9.96855e-16
C2374 FS_N_OUT PULLUP_P_BLEED_5 6.3758e-17
C2375 HS_P_6 PAD_P 1.8306e-15
C2376 FS_P_OUT TERM_N_R 3.85477e-16
C2377 PULLDOWN_N VDD 4.54228e-16
C2378 FS_N_BLEED_2 FS_N_BLEED_3 4.62519e-15
C2379 VDD PULLDOWN_P 1.69557e-15
C2380 DIV_ENABLE TERM_OR_P_B 6.06007e-19
C2381 HS_N_2 HS_P_10 3.08895e-17
C2382 HS_N_6 HS_P_13 5.49271e-17
C2383 HS_P PULLUP_P_OUT 2.40376e-17
C2384 HS_N_10 DIV_LOW_P 2.59079e-18
C2385 TERM_P_R HS_P_1 1.02562e-16
C2386 PULLUP_N_WELL BYPASS_ENABLE 8.22717e-18
C2387 TERM_GATE_N_BLEED_2 FS_HIGH_P 1.34735e-17
C2388 HS_N_8 FS_P_BLEED_4 4.2854e-17
C2389 TERM_ENABLE FS_P_BLEED_6 2.58247e-18
C2390 HS_N_3 TERM_P_R 5.89263e-17
C2391 HS_N_13 HS_N_10 3.79438e-17
C2392 HS_N_11 HS_N_12 1.36661e-13
C2393 PULLUP_N_OUT HS_P_4 8.62998e-17
C2394 HS_N_0 HS_PBIAS 5.90003e-15
C2395 FS_P_BLEED_2 FS_P_OUT 3.04895e-18
C2396 HS_N_12 FS_LOW_P 8.50523e-17
C2397 HS_N_1 PULLUP_P_OUT 2.59854e-17
C2398 TERM_N_R FS_P_WELL 1.58654e-15
C2399 VCM_LOW_OK TERM_OR_P_B 2.10844e-15
C2400 VDD PULLUP_P_BLEED_2 1.76048e-17
C2401 FS_N_OUT DIV_P 2.20134e-15
C2402 PULLUP_P_WELL FS_P_BLEED_4 6.74983e-19
C2403 HS_P_2 HS_P_13 3.6317e-14
C2404 HS_N_11 FS_N_OUT 5.27536e-18
C2405 FS_P_BLEED_2 FS_P_WELL 4.64303e-17
C2406 HS_N_9 TERM_GATE_P_BLEED_0 1.05304e-18
C2407 HS_N_2 PULLUP_P_BLEED_5 5.2499e-17
C2408 TERM_ENABLE PULLUP_N_BLEED_1 6.15064e-17
C2409 TERM_GATE_N_BLEED_1 FS_HIGH_P 1.58071e-16
C2410 HS_N_9 FS_P_GATE 1.0428e-15
C2411 PULLDOWN_N_R HS_N_4 2.40376e-17
C2412 FS_N_BLEED_2 FS_N_BLEED_0 1.17766e-16
C2413 FS_N_OUT FS_LOW_P 4.64263e-16
C2414 HS_P_12 HS_P_8 1.52593e-19
C2415 HS_N_9 VDD 5.07425e-15
C2416 HS_N_4 FS_P_BLEED_0 6.1779e-17
C2417 HS_N_9 HS_P_5 6.57781e-17
C2418 HS_N_8 HS_P_13 4.82763e-17
C2419 HS_N_12 DIV_LOW_P 1.35539e-18
C2420 HS_N_4 HS_P_10 7.70846e-17
C2421 FS_P_GATE FS_P_CONTROL_S 1.43654e-15
C2422 FS_N_BLEED_1 FS_N_BLEED_3 1.20364e-16
C2423 TERM_ENABLE FS_HIGH_P 2.05054e-17
C2424 HS_N_11 HS_N_2 3.50404e-17
C2425 TERM_P_R HS_P_3 1.21358e-16
C2426 HS_N_3 HS_N_10 7.40917e-17
C2427 HS_N_13 HS_N_12 1.35264e-13
C2428 VDD FS_P_CONTROL_S 3.86206e-16
C2429 HS_N_5 TERM_P_R 5.89263e-17
C2430 HS_N_2 FS_LOW_P 2.12547e-16
C2431 HS_N_1 FS_P_BLEED_3 5.71333e-19
C2432 PULLDOWN_N_R HS_P_12 2.40376e-17
C2433 HS_N_11 PULLUP_P_CONTROL_S 3.48887e-17
C2434 TERM_ENABLE FS_N_GATE 1.09657e-15
C2435 FS_N_OUT DIV_LOW_P 5.52472e-17
C2436 FS_N_BLEED_4 FS_HIGH_P 2.0817e-19
C2437 PULLUP_N_BLEED_4 PULLUP_N_BLEED_1 6.85274e-19
C2438 PULLUP_P_BLEED_0 PULLUP_P_BLEED_4 2.57363e-18
C2439 HS_P_2 HS_P_8 3.10308e-17
C2440 PULLUP_P_CONTROL_S FS_LOW_P 8.47923e-17
C2441 HS_N_13 FS_N_OUT 5.51577e-18
C2442 HS_N_4 PULLUP_P_BLEED_5 5.2499e-17
C2443 PULLDOWN_N_R HS_N_6 6.83199e-17
C2444 FS_LOW_N PULLUP_N_BLEED_1 7.12642e-17
C2445 TERM_GATE_N_BLEED_2 HS_N 1.02643e-16
C2446 FS_N_GATE FS_N_BLEED_4 2.13148e-16
C2447 PULLUP_N_BLEED_3 TERM_P_R 2.57363e-18
C2448 FS_N_BLEED_1 FS_N_BLEED_0 1.54554e-15
C2449 TERM_GATE_P_BLEED_0 HS_P_11 3.68876e-17
C2450 HS_N_9 HS_P_4 3.08895e-17
C2451 HS_P_12 HS_P_10 7.58948e-17
C2452 HS_N_6 FS_P_BLEED_0 6.1779e-17
C2453 FS_P_GATE HS_P_11 2.05397e-19
C2454 VDD HS_P_11 5.07627e-15
C2455 FS_N_BLEED_6 PULLUP_N_WELL 2.16428e-17
C2456 TERM_ENABLE PULLDOWN_P_R 4.37656e-17
C2457 TERM_VCM HS_P_13 9.66436e-17
C2458 PULLDOWN_N_R HS_P_2 7.21687e-17
C2459 HS_N_6 HS_P_10 3.09658e-17
C2460 FS_LOW_N FS_HIGH_P 9.38697e-14
C2461 HS_N_10 HS_P_3 2.54545e-17
C2462 HS_N_2 DIV_LOW_P 8.03819e-19
C2463 HS_N_8 HS_P_8 9.06571e-17
C2464 HS_P FS_P_BLEED_5 6.33699e-17
C2465 TERM_P_R TERM_GATE_P 2.6175e-14
C2466 TERM_GATE_N_BLEED_1 HS_N 4.82815e-17
C2467 HS_N_13 HS_N_2 1.25037e-13
C2468 HS_N_11 HS_N_4 4.04393e-19
C2469 HS_N_5 HS_N_10 2.0817e-19
C2470 HS_N_7 TERM_P_R 9.59031e-17
C2471 HS_N_3 HS_N_12 6.41285e-17
C2472 HS_P_5 HS_P_11 3.88115e-17
C2473 HS_N_4 FS_LOW_P 8.50523e-17
C2474 HS_N_1 FS_P_BLEED_5 6.1779e-17
C2475 HS_N_13 PULLUP_P_CONTROL_S 3.48887e-17
C2476 FS_LOW_N FS_N_GATE 7.35085e-16
C2477 TERM_OR_P_NS PULLDOWN_P_R 5.65403e-17
C2478 PULLUP_P_WELL PULLUP_P_BLEED_3 4.57221e-19
C2479 HS_N_3 FS_N_OUT 6.16744e-17
C2480 PULLUP_N_OUT HS_N_0 5.06175e-17
C2481 TERM_GATE_P_BLEED_0 TERM_GATE_P_BLEED_1 2.63577e-15
C2482 HS_P_2 HS_P_10 6.21526e-19
C2483 VDD PULLUP_P_BLEED_4 4.46636e-16
C2484 HS_N_6 PULLUP_P_BLEED_5 5.2499e-17
C2485 TERM_ENABLE HS_N 6.8221e-17
C2486 VDD TERM_GATE_P_BLEED_1 7.12118e-17
C2487 PULLDOWN_N_R HS_N_8 6.83199e-17
C2488 HS_P_12 DIV_P 3.38809e-17
C2489 PULLUP_N_BLEED_2 TERM_P_R 2.57363e-18
C2490 HS_N_11 HS_P_12 6.9135e-17
C2491 HS_N_8 FS_P_BLEED_0 6.1779e-17
C2492 HS_P_9 TERM_OR_P_B 1.442e-16
C2493 HS_P_11 HS_P_4 4.04393e-19
C2494 FS_N_BLEED_4 HS_N 1.1535e-16
C2495 PULLDOWN_N_R PULLUP_P_WELL 4.14822e-16
C2496 FS_LOW_N PULLDOWN_P_R 8.6398e-18
C2497 HS_P_12 FS_LOW_P 1.7418e-16
C2498 HS_N_8 HS_P_10 2.86027e-17
C2499 PULLDOWN_N_R FS_N_BLEED_5 8.85647e-17
C2500 HS_N_12 HS_P_3 2.4816e-17
C2501 TERM_VCM HS_P_8 9.67122e-17
C2502 HS_N_2 HS_P_1 9.79781e-17
C2503 PULLUP_N_BLEED_2 FS_HIGH_N 9.33261e-18
C2504 TERM_VCM PULLUP_P_BLEED_3 9.09595e-17
C2505 HS_N_10 TERM_GATE_P 1.09029e-16
C2506 HS_P FS_P_BLEED_6 6.1779e-17
C2507 HS_N_13 HS_N_4 1.44632e-16
C2508 HS_N_5 HS_N_12 4.04393e-19
C2509 HS_N_11 HS_N_6 2.0817e-19
C2510 HS_N_3 HS_N_2 1.22992e-13
C2511 HS_N_7 HS_N_10 3.02657e-17
C2512 PULLUP_P_WELL FS_P_BLEED_0 6.74983e-19
C2513 TERM_GATE_N TERM_P_R 1.48725e-16
C2514 HS_N_1 FS_P_BLEED_6 6.1779e-17
C2515 HS_N_6 FS_LOW_P 8.54176e-17
C2516 HS_N_3 PULLUP_P_CONTROL_S 3.48887e-17
C2517 FS_N_BLEED_6 HS_PBIAS 4.81135e-17
C2518 PAD_N PULLDOWN_P_R 8.44049e-17
C2519 HS_N_0 PULLDOWN_P 4.42824e-17
C2520 TERM_GATE_P_BLEED_2 TERM_GATE_P_BLEED_1 1.09058e-15
C2521 HS_N_8 PULLUP_P_BLEED_5 5.2499e-17
C2522 PULLUP_N_BLEED_1 HS_P 4.82815e-17
C2523 PULLDOWN_N_R TERM_VCM 3.58985e-16
C2524 FS_LOW_N HS_N 7.68876e-17
C2525 TERM_OR_N_S HS_PBIAS 1.86419e-16
C2526 FS_N_CONTROL_S FS_N_WELL 7.19157e-16
C2527 HS_P_2 FS_LOW_P 4.61847e-17
C2528 HS_N_13 HS_P_12 3.62145e-17
C2529 TERM_VCM FS_P_BLEED_0 1.88962e-17
C2530 PULLUP_P_WELL PULLUP_P_BLEED_5 5.4639e-19
C2531 TERM_GATE_P_BLEED_0 PULLUP_P_OUT 1.01098e-16
C2532 HS_N PAD_N 3.56372e-14
C2533 PULLUP_N_GATE FS_N_BLEED_5 4.58337e-19
C2534 HS_N_9 HS_N_0 3.91118e-17
C2535 TERM_VCM HS_P_10 1.34912e-16
C2536 HS_N_2 HS_P_3 2.45088e-17
C2537 HS_N_4 HS_P_1 5.86785e-17
C2538 FS_P_GATE PULLUP_P_OUT 1.62552e-15
C2539 HS_N_12 TERM_GATE_P 1.08145e-16
C2540 HS_N_5 HS_N_2 1.05682e-18
C2541 HS_N_3 HS_N_4 1.22298e-13
C2542 HS_N_13 HS_N_6 8.10079e-17
C2543 DIV_N TERM_P_R 4.31015e-19
C2544 HS_N_7 HS_N_12 2.95485e-17
C2545 VDD PULLUP_P_OUT 4.02874e-15
C2546 TERM_GATE_N HS_N_10 4.86854e-17
C2547 HS_N_5 PULLUP_P_CONTROL_S 3.48887e-17
C2548 HS_N_8 FS_LOW_P 8.56122e-17
C2549 HS_N_1 FS_HIGH_P 4.92315e-19
C2550 FS_N_GATE HS_P 1.51174e-15
C2551 FS_N_OUT TERM_GATE_P 1.12498e-16
C2552 HS_N_11 PULLUP_P_WELL 2.03505e-16
C2553 PULLUP_N PULLUP_N_BLEED_5 8.99929e-17
C2554 VCM_LOW_OK HS_P_6 3.48887e-17
C2555 HS_N_0 FS_P_CONTROL_S 3.29554e-17
C2556 PULLUP_P_WELL FS_LOW_P 2.72236e-16
C2557 FS_N_BLEED_5 FS_LOW_P 6.63891e-17
C2558 TERM_OR_N_B HS_PBIAS 5.9206e-17
C2559 TERM_N_R TERM_P_R 3.54953e-14
C2560 PULLUP_N_GATE TERM_VCM 2.53557e-16
C2561 HS_P_12 HS_P_1 5.93509e-17
C2562 HS_N_3 HS_P_12 3.48887e-17
C2563 HS_PBIAS FS_N_WELL 3.62026e-15
C2564 FS_P_BLEED_2 TERM_P_R 4.76598e-17
C2565 TERM_N_R FS_HIGH_N 9.51731e-17
C2566 HS_P PULLDOWN_P_R 3.04764e-17
C2567 PULLUP_N_OUT PAD_P 1.11266e-16
C2568 TERM_GATE_P_BLEED_2 PULLUP_P_OUT 4.24183e-17
C2569 HS_N_10 PULLUP_P_BLEED_6 2.44119e-17
C2570 TERM_ENABLE HS_P_13 2.40376e-17
C2571 HS_N_6 HS_P_1 3.09936e-17
C2572 HS_N_2 TERM_GATE_P 1.07473e-16
C2573 HS_N_4 HS_P_3 9.71666e-18
C2574 TERM_VCM DIV_P 1.32183e-16
C2575 FS_P_GATE FS_P_BLEED_3 1.16665e-16
C2576 HS_N_11 TERM_VCM 1.20188e-16
C2577 DIV_N HS_N_10 3.31088e-17
C2578 HS_N_3 HS_N_6 1.05682e-18
C2579 HS_N_13 HS_N_8 5.62374e-17
C2580 HS_N_7 HS_N_2 2.92558e-17
C2581 HS_N_5 HS_N_4 1.21885e-13
C2582 HS_N_1 PULLDOWN_P_R 2.44546e-17
C2583 TERM_GATE_N HS_N_12 4.84401e-17
C2584 HS_PBIAS PULLUP_P_GATE 1.62174e-16
C2585 VDD FS_P_BLEED_3 2.57363e-18
C2586 HS_P_4 PULLUP_P_OUT 5.51888e-17
C2587 TERM_VCM FS_LOW_P 2.47158e-16
C2588 HS_N_7 PULLUP_P_CONTROL_S 3.48887e-17
C2589 FS_P_WELL FS_P_BLEED_1 1.19387e-16
C2590 FS_N_BLEED_3 FS_HIGH_P 2.82661e-19
C2591 HS_N_13 PULLUP_P_WELL 1.86679e-16
C2592 PULLUP_N_WELL DIV_ENABLE 2.58322e-17
C2593 HS_P_13 TERM_OR_P_NS 2.89546e-17
C2594 TERM_GATE_N FS_N_OUT 5.08233e-17
C2595 HS_P_2 HS_P_1 5.6796e-17
C2596 PULLDOWN_N_R PULLUP_N_BLEED_5 4.9343e-17
C2597 FS_N_BLEED_6 PULLUP_N_OUT 5.44487e-17
C2598 PULLDOWN_N_R TERM_GATE_N_BLEED_2 7.92848e-17
C2599 HS_N_10 TERM_N_R 6.03432e-17
C2600 HS_N HS_P 2.27647e-15
C2601 PULLUP_N_BLEED_6 TERM_VCM 2.04122e-17
C2602 FS_N_GATE FS_N_BLEED_3 1.92602e-16
C2603 TERM_N_R TERM_OR_P_S 5.45955e-17
C2604 FS_P_OUT HS_P_0 9.14815e-17
C2605 HS_P_12 HS_P_3 2.89898e-17
C2606 HS_N_5 HS_P_12 6.57781e-17
C2607 FS_P_BLEED_2 HS_N_10 3.47206e-17
C2608 HS_N_1 HS_N 3.90933e-15
C2609 HS_N_0 PULLUP_P_BLEED_4 3.48887e-17
C2610 PULLUP_N_OUT TERM_OR_N_S 1.46572e-16
C2611 HS_N_12 PULLUP_P_BLEED_6 2.42729e-17
C2612 HS_N_6 HS_P_3 3.08895e-17
C2613 TERM_ENABLE HS_P_8 2.40376e-17
C2614 HS_N_8 HS_P_1 2.86636e-17
C2615 TERM_ENABLE PULLUP_P_BLEED_3 1.12285e-16
C2616 TERM_OR_N_S TERM_OR_N_NS 1.63546e-17
C2617 TERM_VCM DIV_LOW_P 2.57067e-18
C2618 HS_N_4 TERM_GATE_P 1.12175e-16
C2619 FS_P_GATE FS_P_BLEED_5 3.07459e-16
C2620 FS_N_BLEED_0 FS_HIGH_P 1.40019e-17
C2621 HS_N_13 TERM_VCM 1.20188e-16
C2622 DIV_N HS_N_12 3.31088e-17
C2623 DIV_LOW_N HS_N_10 6.1779e-17
C2624 HS_N_3 HS_N_8 4.04393e-19
C2625 HS_N_5 HS_N_6 1.21169e-13
C2626 HS_N_7 HS_N_4 6.97616e-17
C2627 TERM_GATE_N HS_N_2 5.05962e-17
C2628 VDD FS_P_BLEED_5 2.57363e-18
C2629 PULLDOWN_N_R TERM_GATE_N_BLEED_1 4.82815e-17
C2630 FS_N_BLEED_0 FS_N_GATE 1.06082e-16
C2631 HS_P_8 TERM_OR_P_NS 2.84614e-17
C2632 HS_N_3 PULLUP_P_WELL 1.80663e-16
C2633 DIV_N FS_N_OUT 7.74836e-17
C2634 HS_P_13 PAD_N 1.69383e-16
C2635 PULLUP_N PULLUP_N_BLEED_4 2.41042e-16
C2636 PULLUP_N_GATE PULLUP_N_BLEED_5 2.62715e-16
C2637 HS_N_5 HS_P_2 3.08895e-17
C2638 HS_P_2 HS_P_3 3.43283e-14
C2639 FS_N_BLEED_6 PULLDOWN_P 4.81135e-17
C2640 HS_N_12 TERM_N_R 5.97047e-17
C2641 PULLDOWN_N_R TERM_ENABLE 1.36385e-16
C2642 HS_N_9 PAD_P 1.20851e-15
C2643 HS_P_12 TERM_GATE_P 1.64522e-16
C2644 HS_N_7 HS_P_12 3.48887e-17
C2645 FS_P_BLEED_2 HS_N_12 3.47206e-17
C2646 TERM_ENABLE FS_P_BLEED_0 8.07085e-17
C2647 TERM_OR_N_S PULLDOWN_P 1.27566e-16
C2648 HS_PBIAS DIV_ENABLE 6.11886e-17
C2649 HS_N_2 PULLUP_P_BLEED_6 2.40376e-17
C2650 TERM_N_R FS_N_OUT 4.38929e-16
C2651 FS_N_BLEED_3 HS_N 1.1535e-16
C2652 PULLUP_N_OUT TERM_OR_N_B 1.37687e-16
C2653 HS_N_8 HS_P_3 2.40376e-17
C2654 TERM_ENABLE HS_P_10 7.67984e-17
C2655 PULLDOWN_N_R FS_N_BLEED_4 8.85647e-17
C2656 PULLDOWN_N_R TERM_OR_P_NS 4.59148e-17
C2657 TERM_VCM HS_P_1 1.50129e-16
C2658 FS_P_GATE FS_P_BLEED_6 5.18505e-15
C2659 TERM_OR_N_B TERM_OR_N_NS 9.45768e-16
C2660 HS_N_6 TERM_GATE_P 1.17846e-16
C2661 HS_P_6 HS_P_9 1.05682e-18
C2662 TERM_GATE_N HS_N_4 4.80752e-17
C2663 DIV_N HS_N_2 3.31088e-17
C2664 DIV_LOW_N HS_N_12 6.1779e-17
C2665 HS_N_3 TERM_VCM 1.24535e-16
C2666 HS_N_7 HS_N_6 1.19754e-13
C2667 HS_N_5 HS_N_8 4.89355e-17
C2668 PULLUP_N_OUT FS_N_WELL 2.29376e-15
C2669 HS_N_11 TERM_GATE_N_BLEED_2 5.26622e-17
C2670 FS_P_BLEED_4 HS_P 8.80433e-17
.ends pad_wired_receive_usb_flat_physical
