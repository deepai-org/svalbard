* Independent exporter of physical Magic .ext; no schematic substitutions.
* Extracted capacitance included; distributed wire resistance remains absent.
.subckt rx_pad_with_discharge_physical PAD_P PAD_N VDD VSS TERM_VCM TERM_ENABLE DIFF_ENABLE DIV_ENABLE BYPASS_ENABLE RX_P RX_N HS_PBIAS HS_P HS_N FS_HIGH_P FS_HIGH_N FS_LOW_P FS_LOW_N PULLUP_P PULLUP_N PULLDOWN_P PULLDOWN_N
X0 PAD_N VSS VSS VSS nfet_06v0_dss w=16u l=0.6u ad=60.48p as=4.48p pd=39.56u ps=32.56u d_sab=3.78u s_sab=0.28u
X1 PAD_N VSS VSS VSS nfet_06v0_dss w=16u l=0.6u ad=60.48p as=4.48p pd=39.56u ps=32.56u d_sab=3.78u s_sab=0.28u
X2 PAD_P VSS VSS VSS nfet_06v0_dss w=16u l=0.6u ad=60.48p as=4.48p pd=39.56u ps=32.56u d_sab=3.78u s_sab=0.28u
X3 PAD_P VSS VSS VSS nfet_06v0_dss w=16u l=0.6u ad=60.48p as=4.48p pd=39.56u ps=32.56u d_sab=3.78u s_sab=0.28u
X4 RX_N VSS VSS ppolyf_u_1k_6p0 r_width=1u r_length=319.54u
X5 RX_P VSS VSS ppolyf_u_1k_6p0 r_width=1u r_length=319.54u
X6 PAD_N BYPASS_ENABLE RX_N VSS nfet_06v0 w=20u l=0.7u ad=8.8p as=8.8p pd=40.88u ps=40.88u
X7 PAD_P BYPASS_ENABLE RX_P VSS nfet_06v0 w=20u l=0.7u ad=8.8p as=8.8p pd=40.88u ps=40.88u
X8 PAD_N BYPASS_ENABLE RX_N VSS nfet_06v0 w=20u l=0.7u ad=8.8p as=8.8p pd=40.88u ps=40.88u
X9 PAD_P BYPASS_ENABLE RX_P VSS nfet_06v0 w=20u l=0.7u ad=8.8p as=8.8p pd=40.88u ps=40.88u
X10 PAD_N BYPASS_ENABLE RX_N VSS nfet_06v0 w=20u l=0.7u ad=8.8p as=8.8p pd=40.88u ps=40.88u
X11 PAD_P BYPASS_ENABLE RX_P VSS nfet_06v0 w=20u l=0.7u ad=8.8p as=8.8p pd=40.88u ps=40.88u
X12 PAD_N BYPASS_ENABLE RX_N VSS nfet_06v0 w=20u l=0.7u ad=8.8p as=8.8p pd=40.88u ps=40.88u
X13 PAD_P FS_P_OUT VSS ppolyf_s r_width=1u r_length=2.16u
X14 PAD_N FS_N_OUT VSS ppolyf_s r_width=1u r_length=2.16u
X15 DIV_P PAD_P VSS ppolyf_u_1k r_width=1u r_length=2u
X16 DIV_N PAD_N VSS ppolyf_u_1k r_width=1u r_length=2u
X17 DIV_P DIV_ENABLE RX_P VSS nfet_06v0 w=20u l=0.7u ad=8.8p as=8.8p pd=40.88u ps=40.88u
X18 DIV_N DIV_ENABLE RX_N VSS nfet_06v0 w=20u l=0.7u ad=8.8p as=8.8p pd=40.88u ps=40.88u
X19 PAD_P BYPASS_ENABLE RX_P VSS nfet_06v0 w=20u l=0.7u ad=8.8p as=8.8p pd=40.88u ps=40.88u
X20 HS_N_12 HS_N PAD_N VSS nfet_06v0 w=20u l=0.7u ad=8.8p as=8.8p pd=40.88u ps=40.88u
X21 HS_P_11 HS_P PAD_P VSS nfet_06v0 w=20u l=0.7u ad=8.8p as=8.8p pd=40.88u ps=40.88u
X22 HS_N_11 HS_N PAD_N VSS nfet_06v0 w=20u l=0.7u ad=8.8p as=8.8p pd=40.88u ps=40.88u
X23 HS_P_10 HS_P PAD_P VSS nfet_06v0 w=20u l=0.7u ad=8.8p as=8.8p pd=40.88u ps=40.88u
X24 HS_N_10 HS_N PAD_N VSS nfet_06v0 w=20u l=0.7u ad=8.8p as=8.8p pd=40.88u ps=40.88u
X25 HS_P_0 HS_P PAD_P VSS nfet_06v0 w=20u l=0.7u ad=8.8p as=8.8p pd=40.88u ps=40.88u
X26 HS_N_0 HS_N PAD_N VSS nfet_06v0 w=20u l=0.7u ad=8.8p as=8.8p pd=40.88u ps=40.88u
X27 HS_P_2 HS_P PAD_P VSS nfet_06v0 w=20u l=0.7u ad=8.8p as=8.8p pd=40.88u ps=40.88u
X28 HS_N_2 HS_N PAD_N VSS nfet_06v0 w=20u l=0.7u ad=8.8p as=8.8p pd=40.88u ps=40.88u
X29 HS_P_1 HS_P PAD_P VSS nfet_06v0 w=20u l=0.7u ad=8.8p as=8.8p pd=40.88u ps=40.88u
X30 HS_N_1 HS_N PAD_N VSS nfet_06v0 w=20u l=0.7u ad=8.8p as=8.8p pd=40.88u ps=40.88u
X31 HS_P_13 HS_P PAD_P VSS nfet_06v0 w=20u l=0.7u ad=8.8p as=8.8p pd=40.88u ps=40.88u
X32 HS_N_13 HS_N PAD_N VSS nfet_06v0 w=20u l=0.7u ad=8.8p as=8.8p pd=40.88u ps=40.88u
X33 HS_P_12 HS_P PAD_P VSS nfet_06v0 w=20u l=0.7u ad=8.8p as=8.8p pd=40.88u ps=40.88u
X34 HS_N_6 HS_N PAD_N VSS nfet_06v0 w=20u l=0.7u ad=8.8p as=8.8p pd=40.88u ps=40.88u
X35 HS_P_5 HS_P PAD_P VSS nfet_06v0 w=20u l=0.7u ad=8.8p as=8.8p pd=40.88u ps=40.88u
X36 HS_N_5 HS_N PAD_N VSS nfet_06v0 w=20u l=0.7u ad=8.8p as=8.8p pd=40.88u ps=40.88u
X37 HS_P_4 HS_P PAD_P VSS nfet_06v0 w=20u l=0.7u ad=8.8p as=8.8p pd=40.88u ps=40.88u
X38 HS_N_4 HS_N PAD_N VSS nfet_06v0 w=20u l=0.7u ad=8.8p as=8.8p pd=40.88u ps=40.88u
X39 HS_P_3 HS_P PAD_P VSS nfet_06v0 w=20u l=0.7u ad=8.8p as=8.8p pd=40.88u ps=40.88u
X40 HS_N_3 HS_N PAD_N VSS nfet_06v0 w=20u l=0.7u ad=8.8p as=8.8p pd=40.88u ps=40.88u
X41 HS_P_9 HS_P PAD_P VSS nfet_06v0 w=20u l=0.7u ad=8.8p as=8.8p pd=40.88u ps=40.88u
X42 HS_N_9 HS_N PAD_N VSS nfet_06v0 w=20u l=0.7u ad=8.8p as=8.8p pd=40.88u ps=40.88u
X43 HS_P_8 HS_P PAD_P VSS nfet_06v0 w=20u l=0.7u ad=8.8p as=8.8p pd=40.88u ps=40.88u
X44 HS_N_8 HS_N PAD_N VSS nfet_06v0 w=20u l=0.7u ad=8.8p as=8.8p pd=40.88u ps=40.88u
X45 HS_P_7 HS_P PAD_P VSS nfet_06v0 w=20u l=0.7u ad=8.8p as=8.8p pd=40.88u ps=40.88u
X46 HS_N_7 HS_N PAD_N VSS nfet_06v0 w=20u l=0.7u ad=8.8p as=8.8p pd=40.88u ps=40.88u
X47 HS_P_6 HS_P PAD_P VSS nfet_06v0 w=20u l=0.7u ad=8.8p as=8.8p pd=40.88u ps=40.88u
X48 VCM_LOW_OK TERM_VCM VSS VSS nfet_03v3 w=8u l=0.28u ad=3.52p as=3.52p pd=16.88u ps=16.88u
X49 TERM_P_R PAD_P VSS ppolyf_s r_width=1u r_length=3.29u
X50 TERM_N_R PAD_N VSS ppolyf_s r_width=1u r_length=3.29u
X51 PAD_P PULLUP_P_OUT VSS ppolyf_u_1k r_width=1u r_length=1.18u
X52 PAD_N PULLUP_N_OUT VSS ppolyf_u_1k r_width=1u r_length=1.18u
X53 PULLDOWN_P_R PAD_P VSS ppolyf_u_1k r_width=1u r_length=14.2u
X54 PULLDOWN_N_R PAD_N VSS ppolyf_u_1k r_width=1u r_length=14.2u
X55 TERM_OR_P_B VCM_LOW_OK TERM_OR_P_S VDD pfet_03v3 w=4u l=0.28u ad=1.76p as=1.76p pd=8.88u ps=8.88u
X56 TERM_OR_P_B FS_LOW_P TERM_OR_P_S VDD pfet_03v3 w=4u l=0.28u ad=1.76p as=1.76p pd=8.88u ps=8.88u
X57 TERM_OR_P_S TERM_ENABLE VDD VDD pfet_03v3 w=4u l=0.28u ad=1.76p as=1.76p pd=8.88u ps=8.88u
X58 TERM_OR_P_NS VCM_LOW_OK VSS VSS nfet_03v3 w=4u l=0.28u ad=1.76p as=1.76p pd=8.88u ps=8.88u
X59 TERM_OR_P_B FS_LOW_P TERM_OR_P_NS VSS nfet_03v3 w=2u l=0.28u ad=0.88p as=0.88p pd=4.88u ps=4.88u
X60 TERM_OR_P_B TERM_ENABLE VSS VSS nfet_03v3 w=2u l=0.28u ad=0.88p as=0.88p pd=4.88u ps=4.88u
X61 VCM_LOW_OK TERM_VCM VDD VDD pfet_03v3 w=2u l=0.28u ad=0.88p as=0.88p pd=4.88u ps=4.88u
X62 TERM_P_R TERM_GATE_P TERM_VCM VSS nfet_03v3 w=20u l=0.28u ad=8.8p as=8.8p pd=40.88u ps=40.88u
X63 VSS TERM_GATE_P_BLEED_2 VSS ppolyf_u_1k r_width=1u r_length=12.5u
X64 TERM_GATE_P_BLEED_2 TERM_GATE_P_BLEED_1 VSS ppolyf_u_1k r_width=1u r_length=12.5u
X65 TERM_GATE_P_BLEED_1 TERM_GATE_P_BLEED_0 VSS ppolyf_u_1k r_width=1u r_length=12.5u
X66 TERM_GATE_P_BLEED_0 TERM_GATE_P VSS ppolyf_u_1k r_width=1u r_length=12.5u
X67 TERM_GATE_P TERM_OR_P_B VDD VDD pfet_03v3 w=8u l=0.28u ad=3.52p as=3.52p pd=16.88u ps=16.88u
X68 TERM_GATE_P TERM_OR_P_B VSS VSS nfet_03v3 w=4u l=0.28u ad=1.76p as=1.76p pd=8.88u ps=8.88u
X69 TERM_P_R TERM_GATE_P TERM_VCM VSS nfet_03v3 w=20u l=0.28u ad=8.8p as=8.8p pd=40.88u ps=40.88u
X70 TERM_P_R TERM_GATE_P TERM_VCM VSS nfet_03v3 w=20u l=0.28u ad=8.8p as=8.8p pd=40.88u ps=40.88u
X71 TERM_P_R TERM_GATE_P TERM_VCM VSS nfet_03v3 w=20u l=0.28u ad=8.8p as=8.8p pd=40.88u ps=40.88u
X72 TERM_P_R TERM_GATE_P TERM_VCM VSS nfet_03v3 w=20u l=0.28u ad=8.8p as=8.8p pd=40.88u ps=40.88u
X73 TERM_P_R TERM_GATE_P TERM_VCM VSS nfet_03v3 w=20u l=0.28u ad=8.8p as=8.8p pd=40.88u ps=40.88u
X74 TERM_P_R TERM_GATE_P TERM_VCM VSS nfet_03v3 w=20u l=0.28u ad=8.8p as=8.8p pd=40.88u ps=40.88u
X75 TERM_P_R TERM_GATE_P TERM_VCM VSS nfet_03v3 w=20u l=0.28u ad=8.8p as=8.8p pd=40.88u ps=40.88u
X76 HS_P_4 HS_PBIAS VDD VDD pfet_03v3 w=20u l=1u ad=8.8p as=8.8p pd=40.88u ps=40.88u
X77 HS_P_3 HS_PBIAS VDD VDD pfet_03v3 w=20u l=1u ad=8.8p as=8.8p pd=40.88u ps=40.88u
X78 HS_P_2 HS_PBIAS VDD VDD pfet_03v3 w=20u l=1u ad=8.8p as=8.8p pd=40.88u ps=40.88u
X79 HS_P_1 HS_PBIAS VDD VDD pfet_03v3 w=20u l=1u ad=8.8p as=8.8p pd=40.88u ps=40.88u
X80 HS_P_0 HS_PBIAS VDD VDD pfet_03v3 w=20u l=1u ad=8.8p as=8.8p pd=40.88u ps=40.88u
X81 DIV_LOW_P DIV_ENABLE VSS VSS nfet_03v3 w=20u l=0.28u ad=8.8p as=8.8p pd=40.88u ps=40.88u
X82 DIV_LOW_P DIV_P VSS ppolyf_u_1k r_width=1u r_length=2u
X83 HS_P_11 HS_PBIAS VDD VDD pfet_03v3 w=20u l=1u ad=8.8p as=8.8p pd=40.88u ps=40.88u
X84 HS_P_10 HS_PBIAS VDD VDD pfet_03v3 w=20u l=1u ad=8.8p as=8.8p pd=40.88u ps=40.88u
X85 HS_P_9 HS_PBIAS VDD VDD pfet_03v3 w=20u l=1u ad=8.8p as=8.8p pd=40.88u ps=40.88u
X86 HS_P_8 HS_PBIAS VDD VDD pfet_03v3 w=20u l=1u ad=8.8p as=8.8p pd=40.88u ps=40.88u
X87 HS_P_7 HS_PBIAS VDD VDD pfet_03v3 w=20u l=1u ad=8.8p as=8.8p pd=40.88u ps=40.88u
X88 HS_P_6 HS_PBIAS VDD VDD pfet_03v3 w=20u l=1u ad=8.8p as=8.8p pd=40.88u ps=40.88u
X89 HS_P_5 HS_PBIAS VDD VDD pfet_03v3 w=20u l=1u ad=8.8p as=8.8p pd=40.88u ps=40.88u
X90 VDD FS_P_GATE FS_P_WELL FS_P_WELL pfet_03v3 w=20u l=0.28u ad=8.8p as=8.8p pd=40.88u ps=40.88u
X91 FS_P_OUT FS_P_GATE FS_P_WELL FS_P_WELL pfet_03v3 w=20u l=0.28u ad=8.8p as=8.8p pd=40.88u ps=40.88u
X92 VDD FS_P_GATE FS_P_WELL FS_P_WELL pfet_03v3 w=20u l=0.28u ad=8.8p as=8.8p pd=40.88u ps=40.88u
X93 FS_P_OUT FS_P_GATE FS_P_WELL FS_P_WELL pfet_03v3 w=20u l=0.28u ad=8.8p as=8.8p pd=40.88u ps=40.88u
X94 VDD FS_P_GATE FS_P_WELL FS_P_WELL pfet_03v3 w=20u l=0.28u ad=8.8p as=8.8p pd=40.88u ps=40.88u
X95 HS_P_13 HS_PBIAS VDD VDD pfet_03v3 w=20u l=1u ad=8.8p as=8.8p pd=40.88u ps=40.88u
X96 HS_P_12 HS_PBIAS VDD VDD pfet_03v3 w=20u l=1u ad=8.8p as=8.8p pd=40.88u ps=40.88u
X97 FS_P_OUT FS_P_GATE FS_P_WELL FS_P_WELL pfet_03v3 w=20u l=0.28u ad=8.8p as=8.8p pd=40.88u ps=40.88u
X98 VDD FS_P_GATE FS_P_WELL FS_P_WELL pfet_03v3 w=20u l=0.28u ad=8.8p as=8.8p pd=40.88u ps=40.88u
X99 FS_P_OUT FS_P_GATE FS_P_WELL FS_P_WELL pfet_03v3 w=20u l=0.28u ad=8.8p as=8.8p pd=40.88u ps=40.88u
X100 VDD FS_P_GATE FS_P_WELL FS_P_WELL pfet_03v3 w=20u l=0.28u ad=8.8p as=8.8p pd=40.88u ps=40.88u
X101 FS_P_OUT FS_P_GATE FS_P_WELL FS_P_WELL pfet_03v3 w=20u l=0.28u ad=8.8p as=8.8p pd=40.88u ps=40.88u
X102 VDD FS_P_GATE FS_P_WELL FS_P_WELL pfet_03v3 w=20u l=0.28u ad=8.8p as=8.8p pd=40.88u ps=40.88u
X103 FS_P_OUT FS_P_GATE FS_P_WELL FS_P_WELL pfet_03v3 w=20u l=0.28u ad=8.8p as=8.8p pd=40.88u ps=40.88u
X104 VDD FS_P_GATE FS_P_WELL FS_P_WELL pfet_03v3 w=20u l=0.28u ad=8.8p as=8.8p pd=40.88u ps=40.88u
X105 FS_P_OUT FS_P_GATE FS_P_WELL FS_P_WELL pfet_03v3 w=20u l=0.28u ad=8.8p as=8.8p pd=40.88u ps=40.88u
X106 VDD FS_P_GATE FS_P_WELL FS_P_WELL pfet_03v3 w=20u l=0.28u ad=8.8p as=8.8p pd=40.88u ps=40.88u
X107 FS_P_OUT FS_P_GATE FS_P_WELL FS_P_WELL pfet_03v3 w=20u l=0.28u ad=8.8p as=8.8p pd=40.88u ps=40.88u
X108 VDD FS_P_GATE FS_P_WELL FS_P_WELL pfet_03v3 w=20u l=0.28u ad=8.8p as=8.8p pd=40.88u ps=40.88u
X109 FS_P_OUT FS_P_GATE FS_P_WELL FS_P_WELL pfet_03v3 w=20u l=0.28u ad=8.8p as=8.8p pd=40.88u ps=40.88u
X110 VDD FS_P_GATE FS_P_WELL FS_P_WELL pfet_03v3 w=20u l=0.28u ad=8.8p as=8.8p pd=40.88u ps=40.88u
X111 FS_P_OUT FS_P_GATE FS_P_WELL FS_P_WELL pfet_03v3 w=20u l=0.28u ad=8.8p as=8.8p pd=40.88u ps=40.88u
X112 VDD FS_P_GATE FS_P_WELL FS_P_WELL pfet_03v3 w=20u l=0.28u ad=8.8p as=8.8p pd=40.88u ps=40.88u
X113 FS_P_OUT FS_P_GATE FS_P_WELL FS_P_WELL pfet_03v3 w=20u l=0.28u ad=8.8p as=8.8p pd=40.88u ps=40.88u
X114 VDD FS_P_GATE FS_P_WELL FS_P_WELL pfet_03v3 w=20u l=0.28u ad=8.8p as=8.8p pd=40.88u ps=40.88u
X115 FS_P_OUT FS_P_GATE FS_P_WELL FS_P_WELL pfet_03v3 w=20u l=0.28u ad=8.8p as=8.8p pd=40.88u ps=40.88u
X116 VDD FS_P_GATE FS_P_WELL FS_P_WELL pfet_03v3 w=20u l=0.28u ad=8.8p as=8.8p pd=40.88u ps=40.88u
X117 FS_P_OUT FS_P_GATE FS_P_WELL FS_P_WELL pfet_03v3 w=20u l=0.28u ad=8.8p as=8.8p pd=40.88u ps=40.88u
X118 VDD FS_P_GATE FS_P_WELL FS_P_WELL pfet_03v3 w=20u l=0.28u ad=8.8p as=8.8p pd=40.88u ps=40.88u
X119 FS_P_OUT FS_P_GATE FS_P_WELL FS_P_WELL pfet_03v3 w=20u l=0.28u ad=8.8p as=8.8p pd=40.88u ps=40.88u
X120 VDD FS_P_GATE FS_P_WELL FS_P_WELL pfet_03v3 w=20u l=0.28u ad=8.8p as=8.8p pd=40.88u ps=40.88u
X121 FS_P_OUT FS_P_GATE FS_P_WELL FS_P_WELL pfet_03v3 w=20u l=0.28u ad=8.8p as=8.8p pd=40.88u ps=40.88u
X122 VDD FS_P_GATE FS_P_WELL FS_P_WELL pfet_03v3 w=20u l=0.28u ad=8.8p as=8.8p pd=40.88u ps=40.88u
X123 FS_P_OUT FS_P_GATE FS_P_WELL FS_P_WELL pfet_03v3 w=20u l=0.28u ad=8.8p as=8.8p pd=40.88u ps=40.88u
X124 VDD FS_P_GATE FS_P_WELL FS_P_WELL pfet_03v3 w=20u l=0.28u ad=8.8p as=8.8p pd=40.88u ps=40.88u
X125 FS_P_OUT FS_P_GATE FS_P_WELL FS_P_WELL pfet_03v3 w=20u l=0.28u ad=8.8p as=8.8p pd=40.88u ps=40.88u
X126 VDD FS_P_GATE FS_P_WELL FS_P_WELL pfet_03v3 w=20u l=0.28u ad=8.8p as=8.8p pd=40.88u ps=40.88u
X127 FS_P_OUT FS_P_GATE FS_P_WELL FS_P_WELL pfet_03v3 w=20u l=0.28u ad=8.8p as=8.8p pd=40.88u ps=40.88u
X128 VDD FS_P_GATE FS_P_WELL FS_P_WELL pfet_03v3 w=20u l=0.28u ad=8.8p as=8.8p pd=40.88u ps=40.88u
X129 FS_P_OUT FS_P_GATE FS_P_WELL FS_P_WELL pfet_03v3 w=20u l=0.28u ad=8.8p as=8.8p pd=40.88u ps=40.88u
X130 VDD FS_P_GATE FS_P_WELL FS_P_WELL pfet_03v3 w=20u l=0.28u ad=8.8p as=8.8p pd=40.88u ps=40.88u
X131 FS_P_OUT FS_P_GATE FS_P_WELL FS_P_WELL pfet_03v3 w=20u l=0.28u ad=8.8p as=8.8p pd=40.88u ps=40.88u
X132 VDD FS_P_GATE FS_P_WELL FS_P_WELL pfet_03v3 w=20u l=0.28u ad=8.8p as=8.8p pd=40.88u ps=40.88u
X133 FS_P_OUT FS_P_GATE FS_P_WELL FS_P_WELL pfet_03v3 w=20u l=0.28u ad=8.8p as=8.8p pd=40.88u ps=40.88u
X134 VDD FS_P_GATE FS_P_WELL FS_P_WELL pfet_03v3 w=20u l=0.28u ad=8.8p as=8.8p pd=40.88u ps=40.88u
X135 FS_P_OUT FS_P_GATE FS_P_WELL FS_P_WELL pfet_03v3 w=20u l=0.28u ad=8.8p as=8.8p pd=40.88u ps=40.88u
X136 VDD FS_P_GATE FS_P_WELL FS_P_WELL pfet_03v3 w=20u l=0.28u ad=8.8p as=8.8p pd=40.88u ps=40.88u
X137 FS_P_OUT FS_P_GATE FS_P_WELL FS_P_WELL pfet_03v3 w=20u l=0.28u ad=8.8p as=8.8p pd=40.88u ps=40.88u
X138 VDD FS_P_GATE FS_P_WELL FS_P_WELL pfet_03v3 w=20u l=0.28u ad=8.8p as=8.8p pd=40.88u ps=40.88u
X139 FS_P_BLEED_2 FS_P_BLEED_1 VSS ppolyf_u_1k r_width=1u r_length=12.5u
X140 FS_P_BLEED_1 FS_P_BLEED_0 VSS ppolyf_u_1k r_width=1u r_length=12.5u
X141 FS_P_BLEED_0 FS_P_WELL VSS ppolyf_u_1k r_width=1u r_length=12.5u
X142 FS_P_GATE VDD FS_P_WELL FS_P_WELL pfet_03v3 w=4u l=0.28u ad=1.76p as=1.76p pd=8.88u ps=8.88u
X143 FS_P_CONTROL_S VDD VSS VSS nfet_03v3 w=4u l=0.28u ad=1.76p as=1.76p pd=8.88u ps=8.88u
X144 FS_P_GATE FS_HIGH_P FS_P_CONTROL_S VSS nfet_06v0 w=2u l=0.7u ad=0.88p as=0.88p pd=4.88u ps=4.88u
X145 FS_P_OUT FS_P_GATE FS_P_WELL FS_P_WELL pfet_03v3 w=20u l=0.28u ad=8.8p as=8.8p pd=40.88u ps=40.88u
X146 PULLUP_P_OUT PULLUP_P_GATE PULLUP_P_WELL PULLUP_P_WELL pfet_03v3 w=20u l=0.28u ad=8.8p as=8.8p pd=40.88u ps=40.88u
X147 VDD PULLUP_P_GATE PULLUP_P_WELL PULLUP_P_WELL pfet_03v3 w=20u l=0.28u ad=8.8p as=8.8p pd=40.88u ps=40.88u
X148 FS_P_GATE FS_P_BLEED_6 VSS ppolyf_u_1k r_width=1u r_length=12.5u
X149 FS_P_BLEED_6 FS_P_BLEED_5 VSS ppolyf_u_1k r_width=1u r_length=12.5u
X150 FS_P_BLEED_5 FS_P_BLEED_4 VSS ppolyf_u_1k r_width=1u r_length=12.5u
X151 FS_P_BLEED_4 FS_P_BLEED_3 VSS ppolyf_u_1k r_width=1u r_length=12.5u
X152 FS_P_BLEED_3 FS_P_BLEED_2 VSS ppolyf_u_1k r_width=1u r_length=12.5u
X153 PULLUP_P_GATE PULLUP_P PULLUP_P_CONTROL_S VSS nfet_06v0 w=2u l=0.7u ad=0.88p as=0.88p pd=4.88u ps=4.88u
X154 PULLUP_P_OUT PULLUP_P_GATE PULLUP_P_WELL PULLUP_P_WELL pfet_03v3 w=20u l=0.28u ad=8.8p as=8.8p pd=40.88u ps=40.88u
X155 VDD PULLUP_P_GATE PULLUP_P_WELL PULLUP_P_WELL pfet_03v3 w=20u l=0.28u ad=8.8p as=8.8p pd=40.88u ps=40.88u
X156 PULLUP_P_OUT PULLUP_P_GATE PULLUP_P_WELL PULLUP_P_WELL pfet_03v3 w=20u l=0.28u ad=8.8p as=8.8p pd=40.88u ps=40.88u
X157 VDD PULLUP_P_GATE PULLUP_P_WELL PULLUP_P_WELL pfet_03v3 w=20u l=0.28u ad=8.8p as=8.8p pd=40.88u ps=40.88u
X158 PULLUP_P_OUT PULLUP_P_GATE PULLUP_P_WELL PULLUP_P_WELL pfet_03v3 w=20u l=0.28u ad=8.8p as=8.8p pd=40.88u ps=40.88u
X159 VDD PULLUP_P_GATE PULLUP_P_WELL PULLUP_P_WELL pfet_03v3 w=20u l=0.28u ad=8.8p as=8.8p pd=40.88u ps=40.88u
X160 PULLUP_P_BLEED_4 PULLUP_P_BLEED_3 VSS ppolyf_u_1k r_width=1u r_length=12.5u
X161 PULLUP_P_BLEED_3 PULLUP_P_BLEED_2 VSS ppolyf_u_1k r_width=1u r_length=12.5u
X162 PULLUP_P_BLEED_2 PULLUP_P_BLEED_1 VSS ppolyf_u_1k r_width=1u r_length=12.5u
X163 PULLUP_P_BLEED_1 PULLUP_P_BLEED_0 VSS ppolyf_u_1k r_width=1u r_length=12.5u
X164 PULLUP_P_BLEED_0 PULLUP_P_WELL VSS ppolyf_u_1k r_width=1u r_length=12.5u
X165 PULLUP_P_GATE VDD PULLUP_P_WELL PULLUP_P_WELL pfet_03v3 w=4u l=0.28u ad=1.76p as=1.76p pd=8.88u ps=8.88u
X166 PULLUP_P_CONTROL_S VDD VSS VSS nfet_03v3 w=4u l=0.28u ad=1.76p as=1.76p pd=8.88u ps=8.88u
X167 TERM_OR_N_NS VCM_LOW_OK VSS VSS nfet_03v3 w=4u l=0.28u ad=1.76p as=1.76p pd=8.88u ps=8.88u
X168 TERM_OR_N_B FS_LOW_N TERM_OR_N_NS VSS nfet_03v3 w=2u l=0.28u ad=0.88p as=0.88p pd=4.88u ps=4.88u
X169 TERM_OR_N_B TERM_ENABLE VSS VSS nfet_03v3 w=2u l=0.28u ad=0.88p as=0.88p pd=4.88u ps=4.88u
X170 PULLDOWN_P_R PULLDOWN_P VSS VSS nfet_03v3 w=8u l=0.28u ad=3.52p as=3.52p pd=16.88u ps=16.88u
X171 PULLUP_P_GATE PULLUP_P_BLEED_6 VSS ppolyf_u_1k r_width=1u r_length=12.5u
X172 PULLUP_P_BLEED_6 PULLUP_P_BLEED_5 VSS ppolyf_u_1k r_width=1u r_length=12.5u
X173 PULLUP_P_BLEED_5 PULLUP_P_BLEED_4 VSS ppolyf_u_1k r_width=1u r_length=12.5u
X174 TERM_GATE_N_BLEED_1 TERM_GATE_N_BLEED_0 VSS ppolyf_u_1k r_width=1u r_length=12.5u
X175 TERM_GATE_N_BLEED_0 TERM_GATE_N VSS ppolyf_u_1k r_width=1u r_length=12.5u
X176 TERM_GATE_N TERM_OR_N_B VDD VDD pfet_03v3 w=8u l=0.28u ad=3.52p as=3.52p pd=16.88u ps=16.88u
X177 TERM_GATE_N TERM_OR_N_B VSS VSS nfet_03v3 w=4u l=0.28u ad=1.76p as=1.76p pd=8.88u ps=8.88u
X178 TERM_OR_N_B VCM_LOW_OK TERM_OR_N_S VDD pfet_03v3 w=4u l=0.28u ad=1.76p as=1.76p pd=8.88u ps=8.88u
X179 TERM_OR_N_B FS_LOW_N TERM_OR_N_S VDD pfet_03v3 w=4u l=0.28u ad=1.76p as=1.76p pd=8.88u ps=8.88u
X180 TERM_OR_N_S TERM_ENABLE VDD VDD pfet_03v3 w=4u l=0.28u ad=1.76p as=1.76p pd=8.88u ps=8.88u
X181 TERM_N_R TERM_GATE_N TERM_VCM VSS nfet_03v3 w=20u l=0.28u ad=8.8p as=8.8p pd=40.88u ps=40.88u
X182 TERM_N_R TERM_GATE_N TERM_VCM VSS nfet_03v3 w=20u l=0.28u ad=8.8p as=8.8p pd=40.88u ps=40.88u
X183 TERM_N_R TERM_GATE_N TERM_VCM VSS nfet_03v3 w=20u l=0.28u ad=8.8p as=8.8p pd=40.88u ps=40.88u
X184 TERM_N_R TERM_GATE_N TERM_VCM VSS nfet_03v3 w=20u l=0.28u ad=8.8p as=8.8p pd=40.88u ps=40.88u
X185 TERM_N_R TERM_GATE_N TERM_VCM VSS nfet_03v3 w=20u l=0.28u ad=8.8p as=8.8p pd=40.88u ps=40.88u
X186 VSS TERM_GATE_N_BLEED_2 VSS ppolyf_u_1k r_width=1u r_length=12.5u
X187 TERM_GATE_N_BLEED_2 TERM_GATE_N_BLEED_1 VSS ppolyf_u_1k r_width=1u r_length=12.5u
X188 HS_N_1 HS_PBIAS VDD VDD pfet_03v3 w=20u l=1u ad=8.8p as=8.8p pd=40.88u ps=40.88u
X189 HS_N_0 HS_PBIAS VDD VDD pfet_03v3 w=20u l=1u ad=8.8p as=8.8p pd=40.88u ps=40.88u
X190 DIV_LOW_N DIV_ENABLE VSS VSS nfet_03v3 w=20u l=0.28u ad=8.8p as=8.8p pd=40.88u ps=40.88u
X191 DIV_LOW_N DIV_N VSS ppolyf_u_1k r_width=1u r_length=2u
X192 TERM_N_R TERM_GATE_N TERM_VCM VSS nfet_03v3 w=20u l=0.28u ad=8.8p as=8.8p pd=40.88u ps=40.88u
X193 TERM_N_R TERM_GATE_N TERM_VCM VSS nfet_03v3 w=20u l=0.28u ad=8.8p as=8.8p pd=40.88u ps=40.88u
X194 TERM_N_R TERM_GATE_N TERM_VCM VSS nfet_03v3 w=20u l=0.28u ad=8.8p as=8.8p pd=40.88u ps=40.88u
X195 HS_N_8 HS_PBIAS VDD VDD pfet_03v3 w=20u l=1u ad=8.8p as=8.8p pd=40.88u ps=40.88u
X196 HS_N_7 HS_PBIAS VDD VDD pfet_03v3 w=20u l=1u ad=8.8p as=8.8p pd=40.88u ps=40.88u
X197 HS_N_6 HS_PBIAS VDD VDD pfet_03v3 w=20u l=1u ad=8.8p as=8.8p pd=40.88u ps=40.88u
X198 HS_N_5 HS_PBIAS VDD VDD pfet_03v3 w=20u l=1u ad=8.8p as=8.8p pd=40.88u ps=40.88u
X199 HS_N_4 HS_PBIAS VDD VDD pfet_03v3 w=20u l=1u ad=8.8p as=8.8p pd=40.88u ps=40.88u
X200 HS_N_3 HS_PBIAS VDD VDD pfet_03v3 w=20u l=1u ad=8.8p as=8.8p pd=40.88u ps=40.88u
X201 HS_N_2 HS_PBIAS VDD VDD pfet_03v3 w=20u l=1u ad=8.8p as=8.8p pd=40.88u ps=40.88u
X202 FS_N_OUT FS_N_GATE FS_N_WELL FS_N_WELL pfet_03v3 w=20u l=0.28u ad=8.8p as=8.8p pd=40.88u ps=40.88u
X203 VDD FS_N_GATE FS_N_WELL FS_N_WELL pfet_03v3 w=20u l=0.28u ad=8.8p as=8.8p pd=40.88u ps=40.88u
X204 HS_N_13 HS_PBIAS VDD VDD pfet_03v3 w=20u l=1u ad=8.8p as=8.8p pd=40.88u ps=40.88u
X205 HS_N_12 HS_PBIAS VDD VDD pfet_03v3 w=20u l=1u ad=8.8p as=8.8p pd=40.88u ps=40.88u
X206 HS_N_11 HS_PBIAS VDD VDD pfet_03v3 w=20u l=1u ad=8.8p as=8.8p pd=40.88u ps=40.88u
X207 HS_N_10 HS_PBIAS VDD VDD pfet_03v3 w=20u l=1u ad=8.8p as=8.8p pd=40.88u ps=40.88u
X208 HS_N_9 HS_PBIAS VDD VDD pfet_03v3 w=20u l=1u ad=8.8p as=8.8p pd=40.88u ps=40.88u
X209 VDD FS_N_GATE FS_N_WELL FS_N_WELL pfet_03v3 w=20u l=0.28u ad=8.8p as=8.8p pd=40.88u ps=40.88u
X210 FS_N_OUT FS_N_GATE FS_N_WELL FS_N_WELL pfet_03v3 w=20u l=0.28u ad=8.8p as=8.8p pd=40.88u ps=40.88u
X211 VDD FS_N_GATE FS_N_WELL FS_N_WELL pfet_03v3 w=20u l=0.28u ad=8.8p as=8.8p pd=40.88u ps=40.88u
X212 FS_N_OUT FS_N_GATE FS_N_WELL FS_N_WELL pfet_03v3 w=20u l=0.28u ad=8.8p as=8.8p pd=40.88u ps=40.88u
X213 VDD FS_N_GATE FS_N_WELL FS_N_WELL pfet_03v3 w=20u l=0.28u ad=8.8p as=8.8p pd=40.88u ps=40.88u
X214 FS_N_OUT FS_N_GATE FS_N_WELL FS_N_WELL pfet_03v3 w=20u l=0.28u ad=8.8p as=8.8p pd=40.88u ps=40.88u
X215 VDD FS_N_GATE FS_N_WELL FS_N_WELL pfet_03v3 w=20u l=0.28u ad=8.8p as=8.8p pd=40.88u ps=40.88u
X216 FS_N_OUT FS_N_GATE FS_N_WELL FS_N_WELL pfet_03v3 w=20u l=0.28u ad=8.8p as=8.8p pd=40.88u ps=40.88u
X217 VDD FS_N_GATE FS_N_WELL FS_N_WELL pfet_03v3 w=20u l=0.28u ad=8.8p as=8.8p pd=40.88u ps=40.88u
X218 FS_N_OUT FS_N_GATE FS_N_WELL FS_N_WELL pfet_03v3 w=20u l=0.28u ad=8.8p as=8.8p pd=40.88u ps=40.88u
X219 VDD FS_N_GATE FS_N_WELL FS_N_WELL pfet_03v3 w=20u l=0.28u ad=8.8p as=8.8p pd=40.88u ps=40.88u
X220 FS_N_OUT FS_N_GATE FS_N_WELL FS_N_WELL pfet_03v3 w=20u l=0.28u ad=8.8p as=8.8p pd=40.88u ps=40.88u
X221 VDD FS_N_GATE FS_N_WELL FS_N_WELL pfet_03v3 w=20u l=0.28u ad=8.8p as=8.8p pd=40.88u ps=40.88u
X222 FS_N_OUT FS_N_GATE FS_N_WELL FS_N_WELL pfet_03v3 w=20u l=0.28u ad=8.8p as=8.8p pd=40.88u ps=40.88u
X223 VDD FS_N_GATE FS_N_WELL FS_N_WELL pfet_03v3 w=20u l=0.28u ad=8.8p as=8.8p pd=40.88u ps=40.88u
X224 FS_N_OUT FS_N_GATE FS_N_WELL FS_N_WELL pfet_03v3 w=20u l=0.28u ad=8.8p as=8.8p pd=40.88u ps=40.88u
X225 VDD FS_N_GATE FS_N_WELL FS_N_WELL pfet_03v3 w=20u l=0.28u ad=8.8p as=8.8p pd=40.88u ps=40.88u
X226 FS_N_OUT FS_N_GATE FS_N_WELL FS_N_WELL pfet_03v3 w=20u l=0.28u ad=8.8p as=8.8p pd=40.88u ps=40.88u
X227 VDD FS_N_GATE FS_N_WELL FS_N_WELL pfet_03v3 w=20u l=0.28u ad=8.8p as=8.8p pd=40.88u ps=40.88u
X228 FS_N_OUT FS_N_GATE FS_N_WELL FS_N_WELL pfet_03v3 w=20u l=0.28u ad=8.8p as=8.8p pd=40.88u ps=40.88u
X229 VDD FS_N_GATE FS_N_WELL FS_N_WELL pfet_03v3 w=20u l=0.28u ad=8.8p as=8.8p pd=40.88u ps=40.88u
X230 FS_N_OUT FS_N_GATE FS_N_WELL FS_N_WELL pfet_03v3 w=20u l=0.28u ad=8.8p as=8.8p pd=40.88u ps=40.88u
X231 VDD FS_N_GATE FS_N_WELL FS_N_WELL pfet_03v3 w=20u l=0.28u ad=8.8p as=8.8p pd=40.88u ps=40.88u
X232 FS_N_OUT FS_N_GATE FS_N_WELL FS_N_WELL pfet_03v3 w=20u l=0.28u ad=8.8p as=8.8p pd=40.88u ps=40.88u
X233 VDD FS_N_GATE FS_N_WELL FS_N_WELL pfet_03v3 w=20u l=0.28u ad=8.8p as=8.8p pd=40.88u ps=40.88u
X234 FS_N_OUT FS_N_GATE FS_N_WELL FS_N_WELL pfet_03v3 w=20u l=0.28u ad=8.8p as=8.8p pd=40.88u ps=40.88u
X235 VDD FS_N_GATE FS_N_WELL FS_N_WELL pfet_03v3 w=20u l=0.28u ad=8.8p as=8.8p pd=40.88u ps=40.88u
X236 FS_N_OUT FS_N_GATE FS_N_WELL FS_N_WELL pfet_03v3 w=20u l=0.28u ad=8.8p as=8.8p pd=40.88u ps=40.88u
X237 VDD FS_N_GATE FS_N_WELL FS_N_WELL pfet_03v3 w=20u l=0.28u ad=8.8p as=8.8p pd=40.88u ps=40.88u
X238 FS_N_OUT FS_N_GATE FS_N_WELL FS_N_WELL pfet_03v3 w=20u l=0.28u ad=8.8p as=8.8p pd=40.88u ps=40.88u
X239 VDD FS_N_GATE FS_N_WELL FS_N_WELL pfet_03v3 w=20u l=0.28u ad=8.8p as=8.8p pd=40.88u ps=40.88u
X240 FS_N_OUT FS_N_GATE FS_N_WELL FS_N_WELL pfet_03v3 w=20u l=0.28u ad=8.8p as=8.8p pd=40.88u ps=40.88u
X241 VDD FS_N_GATE FS_N_WELL FS_N_WELL pfet_03v3 w=20u l=0.28u ad=8.8p as=8.8p pd=40.88u ps=40.88u
X242 FS_N_OUT FS_N_GATE FS_N_WELL FS_N_WELL pfet_03v3 w=20u l=0.28u ad=8.8p as=8.8p pd=40.88u ps=40.88u
X243 VDD FS_N_GATE FS_N_WELL FS_N_WELL pfet_03v3 w=20u l=0.28u ad=8.8p as=8.8p pd=40.88u ps=40.88u
X244 FS_N_OUT FS_N_GATE FS_N_WELL FS_N_WELL pfet_03v3 w=20u l=0.28u ad=8.8p as=8.8p pd=40.88u ps=40.88u
X245 VDD FS_N_GATE FS_N_WELL FS_N_WELL pfet_03v3 w=20u l=0.28u ad=8.8p as=8.8p pd=40.88u ps=40.88u
X246 FS_N_OUT FS_N_GATE FS_N_WELL FS_N_WELL pfet_03v3 w=20u l=0.28u ad=8.8p as=8.8p pd=40.88u ps=40.88u
X247 VDD FS_N_GATE FS_N_WELL FS_N_WELL pfet_03v3 w=20u l=0.28u ad=8.8p as=8.8p pd=40.88u ps=40.88u
X248 FS_N_OUT FS_N_GATE FS_N_WELL FS_N_WELL pfet_03v3 w=20u l=0.28u ad=8.8p as=8.8p pd=40.88u ps=40.88u
X249 VDD FS_N_GATE FS_N_WELL FS_N_WELL pfet_03v3 w=20u l=0.28u ad=8.8p as=8.8p pd=40.88u ps=40.88u
X250 FS_N_OUT FS_N_GATE FS_N_WELL FS_N_WELL pfet_03v3 w=20u l=0.28u ad=8.8p as=8.8p pd=40.88u ps=40.88u
X251 FS_N_GATE VDD FS_N_WELL FS_N_WELL pfet_03v3 w=4u l=0.28u ad=1.76p as=1.76p pd=8.88u ps=8.88u
X252 FS_N_CONTROL_S VDD VSS VSS nfet_03v3 w=4u l=0.28u ad=1.76p as=1.76p pd=8.88u ps=8.88u
X253 FS_N_GATE FS_HIGH_N FS_N_CONTROL_S VSS nfet_06v0 w=2u l=0.7u ad=0.88p as=0.88p pd=4.88u ps=4.88u
X254 FS_N_OUT FS_N_GATE FS_N_WELL FS_N_WELL pfet_03v3 w=20u l=0.28u ad=8.8p as=8.8p pd=40.88u ps=40.88u
X255 VDD FS_N_GATE FS_N_WELL FS_N_WELL pfet_03v3 w=20u l=0.28u ad=8.8p as=8.8p pd=40.88u ps=40.88u
X256 FS_N_OUT FS_N_GATE FS_N_WELL FS_N_WELL pfet_03v3 w=20u l=0.28u ad=8.8p as=8.8p pd=40.88u ps=40.88u
X257 VDD FS_N_GATE FS_N_WELL FS_N_WELL pfet_03v3 w=20u l=0.28u ad=8.8p as=8.8p pd=40.88u ps=40.88u
X258 FS_N_BLEED_6 FS_N_BLEED_5 VSS ppolyf_u_1k r_width=1u r_length=12.5u
X259 FS_N_BLEED_5 FS_N_BLEED_4 VSS ppolyf_u_1k r_width=1u r_length=12.5u
X260 FS_N_BLEED_4 FS_N_BLEED_3 VSS ppolyf_u_1k r_width=1u r_length=12.5u
X261 FS_N_BLEED_3 FS_N_BLEED_2 VSS ppolyf_u_1k r_width=1u r_length=12.5u
X262 FS_N_BLEED_2 FS_N_BLEED_1 VSS ppolyf_u_1k r_width=1u r_length=12.5u
X263 FS_N_BLEED_1 FS_N_BLEED_0 VSS ppolyf_u_1k r_width=1u r_length=12.5u
X264 FS_N_BLEED_0 FS_N_WELL VSS ppolyf_u_1k r_width=1u r_length=12.5u
X265 PULLUP_N_OUT PULLUP_N_GATE PULLUP_N_WELL PULLUP_N_WELL pfet_03v3 w=20u l=0.28u ad=8.8p as=8.8p pd=40.88u ps=40.88u
X266 VDD PULLUP_N_GATE PULLUP_N_WELL PULLUP_N_WELL pfet_03v3 w=20u l=0.28u ad=8.8p as=8.8p pd=40.88u ps=40.88u
X267 PULLUP_N_OUT PULLUP_N_GATE PULLUP_N_WELL PULLUP_N_WELL pfet_03v3 w=20u l=0.28u ad=8.8p as=8.8p pd=40.88u ps=40.88u
X268 VDD PULLUP_N_GATE PULLUP_N_WELL PULLUP_N_WELL pfet_03v3 w=20u l=0.28u ad=8.8p as=8.8p pd=40.88u ps=40.88u
X269 PULLUP_N_OUT PULLUP_N_GATE PULLUP_N_WELL PULLUP_N_WELL pfet_03v3 w=20u l=0.28u ad=8.8p as=8.8p pd=40.88u ps=40.88u
X270 VDD PULLUP_N_GATE PULLUP_N_WELL PULLUP_N_WELL pfet_03v3 w=20u l=0.28u ad=8.8p as=8.8p pd=40.88u ps=40.88u
X271 FS_N_GATE FS_N_BLEED_6 VSS ppolyf_u_1k r_width=1u r_length=12.5u
X272 PULLUP_N_BLEED_1 PULLUP_N_BLEED_0 VSS ppolyf_u_1k r_width=1u r_length=12.5u
X273 PULLUP_N_BLEED_0 PULLUP_N_WELL VSS ppolyf_u_1k r_width=1u r_length=12.5u
X274 PULLUP_N_GATE VDD PULLUP_N_WELL PULLUP_N_WELL pfet_03v3 w=4u l=0.28u ad=1.76p as=1.76p pd=8.88u ps=8.88u
X275 PULLUP_N_CONTROL_S VDD VSS VSS nfet_03v3 w=4u l=0.28u ad=1.76p as=1.76p pd=8.88u ps=8.88u
X276 PULLUP_N_GATE PULLUP_N PULLUP_N_CONTROL_S VSS nfet_06v0 w=2u l=0.7u ad=0.88p as=0.88p pd=4.88u ps=4.88u
X277 PULLUP_N_OUT PULLUP_N_GATE PULLUP_N_WELL PULLUP_N_WELL pfet_03v3 w=20u l=0.28u ad=8.8p as=8.8p pd=40.88u ps=40.88u
X278 VDD PULLUP_N_GATE PULLUP_N_WELL PULLUP_N_WELL pfet_03v3 w=20u l=0.28u ad=8.8p as=8.8p pd=40.88u ps=40.88u
X279 PULLDOWN_N_R PULLDOWN_N VSS VSS nfet_03v3 w=8u l=0.28u ad=3.52p as=3.52p pd=16.88u ps=16.88u
X280 PULLUP_N_GATE PULLUP_N_BLEED_6 VSS ppolyf_u_1k r_width=1u r_length=12.5u
X281 PULLUP_N_BLEED_6 PULLUP_N_BLEED_5 VSS ppolyf_u_1k r_width=1u r_length=12.5u
X282 PULLUP_N_BLEED_5 PULLUP_N_BLEED_4 VSS ppolyf_u_1k r_width=1u r_length=12.5u
X283 PULLUP_N_BLEED_4 PULLUP_N_BLEED_3 VSS ppolyf_u_1k r_width=1u r_length=12.5u
X284 PULLUP_N_BLEED_3 PULLUP_N_BLEED_2 VSS ppolyf_u_1k r_width=1u r_length=12.5u
X285 PULLUP_N_BLEED_2 PULLUP_N_BLEED_1 VSS ppolyf_u_1k r_width=1u r_length=12.5u
X286 TERM_P_R DIFF_ENABLE TERM_N_R VSS nfet_03v3 w=20u l=0.28u ad=8.8p as=8.8p pd=40.88u ps=40.88u
X287 TERM_P_R DIFF_ENABLE TERM_N_R VSS nfet_03v3 w=20u l=0.28u ad=8.8p as=8.8p pd=40.88u ps=40.88u
X288 TERM_P_R DIFF_ENABLE TERM_N_R VSS nfet_03v3 w=20u l=0.28u ad=8.8p as=8.8p pd=40.88u ps=40.88u
X289 TERM_P_R DIFF_ENABLE TERM_N_R VSS nfet_03v3 w=20u l=0.28u ad=8.8p as=8.8p pd=40.88u ps=40.88u
X290 TERM_P_R DIFF_ENABLE TERM_N_R VSS nfet_03v3 w=20u l=0.28u ad=8.8p as=8.8p pd=40.88u ps=40.88u
C14 RX_N VSS 4.03558e-14
C15 RX_P VSS 3.9629e-14
C16 BYPASS_ENABLE VSS 6.04691e-14
C17 HS_N VSS 5.64163e-14
C18 HS_P VSS 4.06952e-14
C24 PAD_P VSS 2.67794e-13
C26 PAD_N VSS 2.82157e-13
C27 TERM_OR_P_S VSS 3.53275e-15
C28 TERM_OR_P_NS VSS 1.00639e-14
C29 FS_LOW_P VSS 3.74596e-14
C31 TERM_GATE_P_BLEED_2 VSS 3.28565e-15
C33 TERM_GATE_P_BLEED_1 VSS 5.10072e-15
C35 TERM_GATE_P_BLEED_0 VSS 7.68181e-15
C37 TERM_OR_P_B VSS 2.1153e-14
C38 TERM_GATE_P VSS 2.70289e-14
C39 HS_P_4 VSS 7.08828e-15
C40 HS_P_3 VSS 7.10742e-15
C41 HS_P_2 VSS 6.92881e-15
C42 HS_P_1 VSS 5.64833e-15
C43 HS_P_0 VSS 7.04643e-15
C44 DIV_LOW_P VSS 7.23693e-15
C46 DIV_P VSS 1.41199e-14
C47 HS_P_11 VSS 8.66739e-15
C48 HS_P_10 VSS 6.56271e-15
C49 HS_P_9 VSS 7.07185e-15
C50 HS_P_8 VSS 5.6877e-15
C51 HS_P_7 VSS 4.83643e-15
C52 HS_P_6 VSS 5.96197e-15
C53 HS_P_5 VSS 7.82827e-15
C54 HS_P_13 VSS 6.12394e-15
C55 HS_P_12 VSS 7.61216e-15
C57 FS_P_BLEED_1 VSS 5.43533e-15
C59 FS_P_BLEED_0 VSS 4.65426e-15
C61 FS_P_CONTROL_S VSS 4.50389e-15
C62 FS_HIGH_P VSS 6.50743e-15
C63 FS_P_OUT VSS 3.32441e-14
C64 FS_P_GATE VSS 5.41782e-14
C66 FS_P_BLEED_6 VSS 4.11494e-15
C68 FS_P_BLEED_5 VSS 3.49709e-15
C70 FS_P_BLEED_4 VSS 3.14909e-15
C72 FS_P_BLEED_3 VSS 3.74647e-15
C74 FS_P_BLEED_2 VSS 8.07498e-15
C75 PULLUP_P VSS 2.03883e-14
C76 PULLUP_P_OUT VSS 1.96241e-14
C78 PULLUP_P_BLEED_3 VSS 4.19596e-15
C80 PULLUP_P_BLEED_2 VSS 3.20038e-15
C82 PULLUP_P_BLEED_1 VSS 3.21015e-15
C84 PULLUP_P_BLEED_0 VSS 5.16157e-15
C86 PULLUP_P_CONTROL_S VSS 6.8319e-15
C87 TERM_OR_N_NS VSS 4.57584e-15
C88 PULLDOWN_P_R VSS 2.08086e-14
C89 PULLDOWN_P VSS 1.31542e-14
C90 PULLUP_P_GATE VSS 2.03625e-14
C92 PULLUP_P_BLEED_6 VSS 8.95891e-15
C94 PULLUP_P_BLEED_5 VSS 1.1915e-14
C96 PULLUP_P_BLEED_4 VSS 8.3128e-15
C98 TERM_GATE_N_BLEED_0 VSS 3.5755e-15
C100 VCM_LOW_OK VSS 1.8323e-14
C101 TERM_OR_N_B VSS 1.05692e-14
C102 FS_LOW_N VSS 8.93339e-15
C103 TERM_OR_N_S VSS 5.67982e-15
C104 TERM_ENABLE VSS 5.04049e-14
C106 TERM_GATE_N_BLEED_2 VSS 1.90723e-14
C108 TERM_GATE_N_BLEED_1 VSS 8.32567e-15
C109 HS_N_1 VSS 1.08501e-14
C110 HS_N_0 VSS 1.15294e-14
C111 DIV_ENABLE VSS 2.24642e-14
C112 DIV_LOW_N VSS 7.76439e-15
C114 DIV_N VSS 1.81827e-14
C115 TERM_VCM VSS 1.14924e-13
C116 TERM_GATE_N VSS 1.61057e-14
C117 HS_N_8 VSS 9.4609e-15
C118 HS_N_7 VSS 8.02897e-15
C119 HS_N_6 VSS 8.95527e-15
C120 HS_N_5 VSS 8.31305e-15
C121 HS_N_4 VSS 7.38867e-15
C122 HS_N_3 VSS 7.80958e-15
C123 HS_N_2 VSS 9.75539e-15
C124 HS_N_13 VSS 8.71443e-15
C125 HS_N_12 VSS 9.8184e-15
C126 HS_N_11 VSS 9.16147e-15
C127 HS_N_10 VSS 8.85941e-15
C128 HS_N_9 VSS 9.6175e-15
C129 HS_PBIAS VSS 4.92915e-14
C130 FS_N_CONTROL_S VSS 5.47781e-15
C131 FS_HIGH_N VSS 3.6476e-15
C132 FS_N_OUT VSS 6.69277e-14
C134 FS_N_BLEED_5 VSS 5.98424e-15
C136 FS_N_BLEED_4 VSS 4.95494e-15
C138 FS_N_BLEED_3 VSS 4.38381e-15
C140 FS_N_BLEED_2 VSS 3.88023e-15
C142 FS_N_BLEED_1 VSS 3.51417e-15
C144 FS_N_BLEED_0 VSS 3.2728e-15
C146 FS_N_GATE VSS 5.766e-14
C148 FS_N_BLEED_6 VSS 8.07787e-15
C150 PULLUP_N_BLEED_0 VSS 4.40019e-15
C152 PULLUP_N_CONTROL_S VSS 4.58281e-15
C153 PULLUP_N VSS 3.16537e-15
C154 PULLUP_N_OUT VSS 4.42339e-14
C155 PULLDOWN_N_R VSS 3.63783e-14
C156 PULLDOWN_N VSS 5.09355e-15
C157 PULLUP_N_GATE VSS 1.27893e-14
C159 PULLUP_N_BLEED_6 VSS 3.40901e-15
C161 PULLUP_N_BLEED_5 VSS 3.00905e-15
C163 PULLUP_N_BLEED_4 VSS 4.15562e-15
C165 PULLUP_N_BLEED_3 VSS 6.97402e-15
C167 PULLUP_N_BLEED_2 VSS 9.92042e-15
C169 PULLUP_N_BLEED_1 VSS 8.17871e-15
C170 TERM_P_R VSS 9.55258e-14
C171 TERM_N_R VSS 1.19378e-13
C172 DIFF_ENABLE VSS 1.42384e-14
C173 FS_P_WELL VSS 5.41093e-13
C174 PULLUP_P_WELL VSS 9.66713e-14
C175 VDD VSS 7.3052e-13
C176 FS_N_WELL VSS 5.52665e-13
C177 PULLUP_N_WELL VSS 9.51067e-14
C178 PULLUP_N_WELL FS_LOW_P 2.2587e-16
C179 FS_N_OUT HS_P_5 6.16744e-17
C180 PULLDOWN_N_R PULLUP_P_BLEED_6 9.19551e-17
C181 PAD_N BYPASS_ENABLE 1.16896e-14
C182 FS_LOW_P TERM_OR_P_NS 3.97232e-16
C183 PULLUP_N_OUT FS_N_BLEED_4 1.01235e-16
C184 HS_N_8 FS_P_GATE 1.03439e-15
C185 HS_N_2 DIV_LOW_N 6.1779e-17
C186 DIV_N FS_P_GATE 9.34087e-17
C187 FS_N_BLEED_0 FS_N_GATE 1.06082e-16
C188 HS_N_2 HS_P_11 3.08895e-17
C189 HS_N_8 HS_P_5 5.89263e-17
C190 HS_N_10 HS_P_0 6.98931e-17
C191 HS_N_7 HS_N_1 7.3898e-17
C192 HS_N_9 TERM_OR_N_S 7.33658e-17
C193 HS_P PULLUP_P_BLEED_0 1.53654e-18
C194 HS_PBIAS HS_P_4 8.54683e-15
C195 PULLUP_N_OUT HS_N_13 4.37656e-17
C196 DIV_N HS_P_5 1.20294e-17
C197 TERM_P_R PULLUP_P_BLEED_3 1.11411e-16
C198 TERM_N_R FS_N_WELL 1.69175e-15
C199 TERM_VCM FS_LOW_P 2.47158e-16
C200 HS_P_1 TERM_GATE_P_BLEED_0 5.5249e-17
C201 HS_N_10 TERM_N_R 6.03432e-17
C202 PULLUP_P PULLUP_P_BLEED_5 1.5607e-16
C203 FS_N_CONTROL_S PULLDOWN_P 9.19309e-17
C204 BYPASS_ENABLE PAD_P 8.2284e-15
C205 HS_N_9 PULLUP_P_WELL 2.12663e-16
C206 VCM_LOW_OK HS_P_12 3.48887e-17
C207 PULLDOWN_P_R FS_P_OUT 7.56607e-16
C208 VDD PULLUP_N_OUT 5.36442e-15
C209 PULLDOWN_N_R PULLUP_P_BLEED_5 9.19551e-17
C210 HS_N_8 HS_P_8 9.06571e-17
C211 PULLUP_P PULLUP_P_GATE 3.89342e-15
C212 PULLDOWN_P DIFF_ENABLE 1.10108e-16
C213 PULLDOWN_N_R PULLUP_P_GATE 2.22433e-16
C214 HS_N_4 DIV_LOW_N 6.1779e-17
C215 HS_P_3 HS_P_2 3.43283e-14
C216 FS_LOW_N TERM_OR_N_S 5.41599e-16
C217 TERM_P_R HS_N_0 9.87585e-17
C218 HS_N_12 HS_P_0 4.37776e-17
C219 HS_N_11 TERM_OR_N_S 6.33501e-17
C220 HS_N_4 HS_P_11 6.60582e-17
C221 PULLUP_N_OUT HS_N_3 2.32186e-18
C222 TERM_P_R TERM_OR_P_S 2.01371e-15
C223 HS_N_8 HS_P_7 9.18219e-17
C224 DIV_ENABLE HS_N_1 3.52797e-17
C225 HS_P_6 FS_P_OUT 1.56731e-16
C226 FS_P_GATE VCM_LOW_OK 1.26536e-15
C227 HS_N_12 TERM_N_R 5.97047e-17
C228 HS_N_11 PULLUP_P_WELL 2.03505e-16
C229 VCM_LOW_OK HS_P_5 3.48887e-17
C230 VDD PULLDOWN_N 4.54228e-16
C231 PULLUP_P PULLDOWN_P_R 6.95504e-19
C232 BYPASS_ENABLE DIV_LOW_P 6.21526e-19
C233 FS_P_BLEED_5 HS_P 6.33699e-17
C234 PULLDOWN_N_R FS_P_BLEED_6 1.03778e-16
C235 PULLUP_P_WELL PULLUP_P_OUT 3.20321e-14
C236 PAD_N HS_N_9 1.0992e-15
C237 PULLDOWN_N_R PULLDOWN_P_R 3.30605e-14
C238 HS_P_3 TERM_OR_P_B 1.02378e-16
C239 HS_N_6 DIV_LOW_N 6.1779e-17
C240 TERM_GATE_N FS_HIGH_P 4.15499e-18
C241 TERM_GATE_P FS_P_OUT 2.28139e-16
C242 HS_P_8 VCM_LOW_OK 3.48887e-17
C243 TERM_P_R TERM_GATE_N_BLEED_1 4.76598e-17
C244 HS_N HS_N_0 1.34018e-13
C245 HS_N_2 HS_P_0 3.72247e-17
C246 HS_N_6 HS_P_11 3.08895e-17
C247 HS_P_2 HS_P_10 6.21526e-19
C248 HS_N_13 TERM_OR_N_S 6.33501e-17
C249 HS_N_8 HS_P_9 6.48683e-18
C250 PULLUP_N_OUT HS_N_5 1.84015e-17
C251 DIV_ENABLE PULLUP_N_BLEED_2 2.67272e-19
C252 HS_N_2 TERM_N_R 6.24464e-17
C253 FS_LOW_N PULLDOWN_P 8.21471e-17
C254 FS_P_WELL TERM_N_R 1.58654e-15
C255 PULLDOWN_N_R HS_P_6 2.41417e-17
C256 HS_N_9 PAD_P 1.20851e-15
C257 HS_N_13 PULLUP_P_WELL 1.86679e-16
C258 VDD TERM_OR_N_S 1.35629e-14
C259 PULLUP_N_BLEED_3 PULLUP_N_BLEED_2 3.56186e-15
C260 VCM_LOW_OK HS_P_7 3.48887e-17
C261 PULLDOWN_P_R FS_P_BLEED_0 1.01235e-16
C262 TERM_N_R FS_P_BLEED_1 1.14443e-16
C263 FS_N_OUT DIV_LOW_N 1.1535e-16
C264 PULLUP_P PULLUP_P_CONTROL_S 3.928e-15
C265 HS_N_0 FS_LOW_P 8.51626e-17
C266 PULLDOWN_N_R PULLUP_P_CONTROL_S 5.46167e-17
C267 PAD_N HS_N_11 1.22201e-15
C268 TERM_OR_P_S FS_LOW_P 3.65441e-16
C269 FS_N_GATE HS_P 1.51174e-15
C270 PULLUP_P TERM_OR_N_B 1.35721e-16
C271 HS_N_8 DIV_LOW_N 6.1779e-17
C272 VDD PULLUP_P_WELL 2.94887e-14
C273 DIV_N DIV_LOW_N 5.26099e-15
C274 HS_N TERM_GATE_N_BLEED_1 4.82815e-17
C275 HS_N_8 HS_P_11 2.85655e-17
C276 FS_N_BLEED_4 PULLDOWN_P 8.85647e-17
C277 HS_N_4 HS_P_0 3.43222e-17
C278 HS_N_3 TERM_OR_N_S 6.48797e-17
C279 TERM_OR_P_B HS_P_10 9.64357e-17
C280 PAD_N PULLUP_P_OUT 2.0199e-16
C281 PULLUP_N_OUT HS_N_7 5.81182e-17
C282 PULLDOWN_N_R TERM_OR_N_B 8.06407e-17
C283 HS_N_11 FS_P_BLEED_3 1.63187e-19
C284 PULLDOWN_N_R TERM_GATE_P 2.62131e-16
C285 FS_P_GATE PULLUP_P_GATE 5.69672e-17
C286 HS_N_0 RX_N 3.048e-18
C287 HS_N_4 TERM_N_R 5.89263e-17
C288 HS_N_13 PULLDOWN_P 4.42824e-17
C289 FS_N_BLEED_1 FS_N_OUT 1.30789e-20
C290 HS_N_3 PULLUP_P_WELL 1.80663e-16
C291 HS_N_11 PAD_P 3.88485e-16
C292 PULLDOWN_P_R HS_P_12 2.40376e-17
C293 VCM_LOW_OK HS_P_9 4.57952e-17
C294 PULLUP_P PULLUP_P_BLEED_0 8.52781e-16
C295 FS_N_BLEED_3 FS_N_BLEED_2 4.62519e-15
C296 HS_PBIAS PULLUP_P_BLEED_4 4.82815e-17
C297 TERM_P_R TERM_ENABLE 5.42615e-16
C298 TERM_GATE_N_BLEED_1 FS_LOW_P 6.27135e-17
C299 PAD_N HS_N_13 1.56314e-15
C300 PAD_P PULLUP_P_OUT 4.38071e-16
C301 PULLDOWN_N_R PULLUP_P_BLEED_0 5.77908e-17
C302 VDD PULLDOWN_P 1.69557e-15
C303 PULLUP_N_OUT FS_N_BLEED_3 5.21642e-17
C304 TERM_P_R FS_N_BLEED_5 1.11411e-16
C305 HS_P_2 TERM_OR_P_NS 2.84614e-17
C306 HS_N TERM_GATE_N_BLEED_2 1.02643e-16
C307 HS_N_6 HS_P_0 3.7366e-17
C308 HS_N_4 HS_P_4 6.84267e-19
C309 HS_N_5 TERM_OR_N_S 6.59331e-17
C310 PULLUP_N_OUT DIV_ENABLE 5.06175e-17
C311 HS_P_6 HS_P_12 7.01805e-17
C312 FS_P_BLEED_6 FS_P_GATE 5.18505e-15
C313 VDD PAD_N 4.57162e-18
C314 FS_P_GATE PULLDOWN_P_R 1.5993e-15
C315 HS_N_6 TERM_N_R 5.89263e-17
C316 PULLUP_N_OUT PULLUP_N_BLEED_3 1.30789e-20
C317 TERM_VCM HS_P_2 9.61503e-17
C318 HS_P_3 HS_P_13 2.65102e-16
C319 HS_N_13 PAD_P 8.1518e-17
C320 BYPASS_ENABLE RX_P 4.95631e-15
C321 HS_N_5 PULLUP_P_WELL 1.7988e-16
C322 PULLDOWN_P_R HS_P_5 2.40376e-17
C323 VCM_LOW_OK HS_P_11 6.67267e-17
C324 TERM_GATE_P_BLEED_1 TERM_GATE_P_BLEED_2 1.09058e-15
C325 PAD_N DIV_P 4.74791e-16
C326 VDD FS_P_BLEED_3 2.57363e-18
C327 HS_N_11 DIV_LOW_P 1.842e-18
C328 TERM_GATE_N_BLEED_2 FS_LOW_P 5.87202e-17
C329 HS_N_10 PULLUP_P_BLEED_4 3.48887e-17
C330 HS_N TERM_ENABLE 6.8221e-17
C331 PAD_N HS_N_3 1.66755e-15
C332 HS_N FS_N_BLEED_5 1.1535e-16
C333 VDD PAD_P 6.48801e-19
C334 FS_N_OUT TERM_N_R 4.38929e-16
C335 HS_P_8 PULLDOWN_P_R 8.55367e-17
C336 TERM_GATE_P HS_P_12 1.64522e-16
C337 TERM_OR_P_B TERM_OR_P_NS 3.40561e-15
C338 TERM_VCM TERM_GATE_N 2.64092e-14
C339 PULLUP_N_OUT HS_N_1 5.06175e-17
C340 TERM_P_R FS_N_CONTROL_S 4.14006e-17
C341 HS_N_8 HS_P_0 3.52283e-17
C342 HS_N_7 TERM_OR_N_S 6.82648e-17
C343 HS_N_6 HS_P_4 3.73763e-17
C344 HS_N BYPASS_ENABLE 1.04923e-17
C345 HS_P_6 HS_P_5 3.23343e-14
C346 HS_P_3 HS_P_1 6.15392e-17
C347 PAD_P DIV_P 2.52939e-15
C348 FS_P_BLEED_5 PULLDOWN_N_R 5.93072e-17
C349 HS_N_8 TERM_N_R 1.16571e-16
C350 HS_N_5 PULLDOWN_P 5.30255e-17
C351 TERM_N_R DIV_N 1.97875e-16
C352 TERM_ENABLE FS_LOW_P 2.00401e-16
C353 TERM_VCM TERM_OR_P_B 6.30322e-17
C354 HS_N_3 PAD_P 9.10423e-17
C355 TERM_P_R DIFF_ENABLE 2.11502e-15
C356 HS_N_7 PULLUP_P_WELL 1.90177e-16
C357 PULLDOWN_P_R HS_P_7 2.41139e-17
C358 FS_N_BLEED_5 FS_LOW_P 6.63891e-17
C359 FS_HIGH_N FS_HIGH_P 3.05739e-14
C360 HS_N_13 DIV_LOW_P 1.02945e-18
C361 HS_P_6 HS_P_8 2.0615e-18
C362 HS_N_12 PULLUP_P_BLEED_4 3.48887e-17
C363 HS_P_13 HS_P_10 9.46582e-17
C364 PAD_N HS_N_5 1.1645e-15
C365 PULLUP_N_OUT TERM_GATE_P_BLEED_1 5.31754e-17
C366 TERM_GATE_P HS_P_5 1.55986e-16
C367 HS_N_8 HS_P_4 2.40376e-17
C368 HS_N_6 TERM_GATE_P_BLEED_0 4.38619e-19
C369 HS_N FS_N_CONTROL_S 1.18717e-16
C370 TERM_P_R HS_N_9 5.92021e-17
C371 HS_PBIAS HS_P_3 6.23881e-15
C372 HS_P_6 HS_P_7 3.16746e-14
C373 FS_N_GATE PULLUP_P 1.05236e-15
C374 HS_P_8 TERM_GATE_P 1.55077e-16
C375 HS_P_10 HS_P_1 3.70279e-14
C376 HS_N_7 PULLDOWN_P 4.42824e-17
C377 HS_N_5 PAD_P 3.42428e-16
C378 DIV_ENABLE PULLUP_P_WELL 1.34291e-17
C379 BYPASS_ENABLE RX_N 7.14256e-15
C380 HS_N DIFF_ENABLE 2.23167e-16
C381 DIV_P DIV_LOW_P 5.03985e-16
C382 VCM_LOW_OK HS_P_0 4.12239e-17
C383 PULLDOWN_P_R HS_P_9 7.46551e-17
C384 FS_N_GATE PULLDOWN_N_R 1.21497e-15
C385 TERM_VCM TERM_OR_N_NS 5.97433e-17
C386 HS_PBIAS FS_HIGH_P 3.86543e-17
C387 HS_N_2 PULLUP_P_BLEED_4 3.48887e-17
C388 TERM_N_R VCM_LOW_OK 1.46988e-16
C389 FS_N_CONTROL_S FS_LOW_P 4.63397e-17
C390 PAD_N HS_N_7 1.7635e-15
C391 TERM_OR_N_S TERM_GATE_N_BLEED_0 1.78914e-18
C392 HS_PBIAS FS_P_BLEED_2 4.81135e-17
C393 TERM_GATE_P HS_P_7 1.55077e-16
C394 PULLUP_N_BLEED_0 PULLUP_N 7.9203e-16
C395 TERM_P_R FS_LOW_N 1.05074e-16
C396 HS_N_1 TERM_OR_N_S 6.33501e-17
C397 HS_N_10 HS_P_3 2.54545e-17
C398 TERM_P_R HS_N_11 5.99647e-17
C399 HS_N HS_N_9 5.92574e-15
C400 HS_P FS_P_OUT 6.85311e-16
C401 FS_LOW_P DIFF_ENABLE 2.20905e-16
C402 FS_N_BLEED_3 PULLDOWN_P 9.71242e-17
C403 HS_N_8 TERM_GATE_P_BLEED_0 7.58005e-19
C404 HS_P_6 HS_P_9 1.05682e-18
C405 PULLUP_N HS_P 1.90282e-18
C406 HS_PBIAS HS_P_10 8.55407e-15
C407 TERM_P_R PULLUP_P_OUT 3.04893e-16
C408 DIV_ENABLE PULLDOWN_P 4.42824e-17
C409 VCM_LOW_OK HS_P_4 6.67267e-17
C410 PULLDOWN_P_R HS_P_11 7.46551e-17
C411 HS_N_7 PAD_P 3.8292e-17
C412 HS_N_1 PULLUP_P_WELL 2.30153e-16
C413 FS_N_WELL FS_HIGH_P 1.84613e-15
C414 PULLUP_N_BLEED_3 PULLDOWN_P 6.51694e-17
C415 HS_N_0 TERM_GATE_N 5.23782e-17
C416 HS_P_13 TERM_OR_P_NS 2.89546e-17
C417 HS_N_10 FS_HIGH_P 3.83793e-19
C418 HS_N_4 PULLUP_P_BLEED_4 3.48887e-17
C419 PULLUP_N_BLEED_0 PULLUP_P 1.04417e-16
C420 FS_P_BLEED_5 FS_P_GATE 3.07459e-16
C421 PAD_N DIV_ENABLE 3.38188e-17
C422 HS_N_9 FS_LOW_P 2.13257e-16
C423 HS_N_10 FS_P_BLEED_2 3.47206e-17
C424 PULLUP_N_OUT FS_N_BLEED_2 7.24459e-19
C425 TERM_P_R FS_N_BLEED_4 4.58761e-17
C426 TERM_GATE_P HS_P_9 2.20515e-16
C427 HS_N_0 TERM_OR_P_B 7.49662e-17
C428 PULLUP_N_BLEED_0 PULLDOWN_N_R 6.21526e-19
C429 HS_N FS_LOW_N 7.68876e-17
C430 TERM_VCM HS_P_13 9.66436e-17
C431 HS_P FS_P_CONTROL_S 3.24645e-17
C432 TERM_OR_P_S TERM_OR_P_B 1.83456e-15
C433 HS_N_12 HS_P_3 2.4816e-17
C434 TERM_P_R HS_N_13 5.95247e-17
C435 HS_N HS_N_11 5.51295e-15
C436 DIV_ENABLE FS_P_BLEED_3 2.67272e-19
C437 HS_P_6 HS_P_11 6.71316e-17
C438 PULLUP_N_WELL FS_HIGH_N 1.41894e-16
C439 PULLDOWN_N_R HS_P 4.19789e-17
C440 HS_N_10 HS_P_10 9.28844e-17
C441 HS_P_1 TERM_OR_P_NS 4.31214e-17
C442 HS_N_1 PULLDOWN_P 4.42824e-17
C443 HS_N PULLUP_P_OUT 9.5159e-17
C444 DIV_ENABLE PAD_P 1.46818e-16
C445 VDD TERM_P_R 6.10049e-15
C446 TERM_GATE_N_BLEED_1 TERM_GATE_N 5.63118e-16
C447 HS_N_12 FS_HIGH_P 2.44156e-19
C448 FS_LOW_N FS_LOW_P 9.39795e-14
C449 TERM_N_R PULLUP_P_GATE 2.08331e-16
C450 HS_N_6 PULLUP_P_BLEED_4 3.48887e-17
C451 HS_N_11 FS_LOW_P 8.50523e-17
C452 PAD_N HS_N_1 1.13339e-15
C453 TERM_VCM HS_P_1 1.50052e-16
C454 HS_N_12 FS_P_BLEED_2 3.47206e-17
C455 HS_N FS_N_BLEED_4 1.1535e-16
C456 TERM_P_R DIV_P 2.24156e-17
C457 PULLUP_N_BLEED_0 PULLUP_N_GATE 2.01392e-16
C458 TERM_GATE_P HS_P_11 1.73603e-16
C459 PULLUP_P_OUT FS_LOW_P 6.60399e-17
C460 TERM_P_R HS_N_3 5.89263e-17
C461 HS_P FS_P_BLEED_0 6.1779e-17
C462 HS_N_2 HS_P_3 2.45088e-17
C463 HS_N HS_N_13 9.82024e-16
C464 PULLUP_N_WELL PULLUP_N_CONTROL_S 8.37127e-17
C465 PULLUP_N_WELL HS_PBIAS 4.6702e-16
C466 HS_N_1 FS_P_BLEED_3 5.71333e-19
C467 RX_P DIV_P 1.39534e-15
C468 FS_N_BLEED_6 FS_N_BLEED_0 7.62796e-18
C469 HS_N_12 HS_P_10 4.37115e-17
C470 PULLUP_N_GATE HS_P 1.18496e-16
C471 FS_N_OUT PULLUP_P_BLEED_4 6.16744e-17
C472 PULLDOWN_P_R HS_P_0 3.03728e-17
C473 HS_N_1 PAD_P 4.82136e-16
C474 FS_N_BLEED_4 FS_LOW_P 8.10079e-17
C475 PULLUP_N_BLEED_2 PULLDOWN_P 6.51694e-17
C476 TERM_GATE_N_BLEED_2 TERM_GATE_N 4.06393e-16
C477 VDD HS_N 2.63612e-15
C478 HS_N_2 FS_HIGH_P 1.12441e-17
C479 FS_P_WELL FS_HIGH_P 1.22539e-15
C480 DIV_ENABLE DIV_LOW_P 2.67093e-15
C481 HS_N_8 PULLUP_P_BLEED_4 3.48887e-17
C482 HS_P_2 TERM_ENABLE 6.39171e-17
C483 HS_PBIAS TERM_VCM 8.64504e-16
C484 HS_N_13 FS_LOW_P 8.50523e-17
C485 DIV_N PULLUP_P_BLEED_4 1.0151e-16
C486 HS_N_2 FS_P_BLEED_2 3.47206e-17
C487 HS_N_0 FS_P_BLEED_4 2.97265e-17
C488 FS_P_BLEED_1 FS_HIGH_P 5.62196e-19
C489 HS_N DIV_P 8.00466e-17
C490 FS_P_WELL FS_P_BLEED_2 4.64303e-17
C491 HS_P HS_P_12 3.63983e-15
C492 FS_P_BLEED_2 FS_P_BLEED_1 8.68609e-15
C493 TERM_P_R HS_N_5 5.89263e-17
C494 PULLUP_N_OUT TERM_OR_N_S 1.46572e-16
C495 HS_N_4 HS_P_3 9.71666e-18
C496 HS_N HS_N_3 2.50774e-15
C497 HS_P_6 HS_P_0 4.60348e-17
C498 VDD FS_LOW_P 4.01828e-15
C499 FS_N_BLEED_6 FS_N_GATE 1.43361e-15
C500 TERM_ENABLE TERM_GATE_N 1.07923e-14
C501 HS_N_2 HS_P_10 3.08895e-17
C502 PULLDOWN_P_R HS_P_4 7.46551e-17
C503 FS_P_OUT FS_P_CONTROL_S 7.9114e-19
C504 PULLUP_N_OUT PULLUP_P_WELL 6.00477e-16
C505 HS_N_0 HS_P_13 2.66122e-17
C506 TERM_VCM FS_N_WELL 2.07231e-15
C507 DIV_P FS_LOW_P 2.36145e-15
C508 HS_N_1 DIV_LOW_P 3.76364e-18
C509 TERM_OR_P_B TERM_ENABLE 5.36669e-15
C510 TERM_N_R PULLUP_P_CONTROL_S 6.05784e-17
C511 HS_N_10 TERM_VCM 1.20188e-16
C512 PULLDOWN_N_R FS_P_OUT 6.89858e-16
C513 HS_N_3 FS_LOW_P 8.50523e-17
C514 HS_P FS_P_GATE 1.05516e-15
C515 HS_N_4 FS_P_BLEED_2 3.47206e-17
C516 PULLUP_N PULLDOWN_N_R 9.20472e-17
C517 TERM_GATE_P HS_P_0 2.58368e-16
C518 HS_N_6 HS_P_3 3.08895e-17
C519 TERM_N_R TERM_OR_N_B 5.99904e-15
C520 TERM_P_R HS_N_7 9.59031e-17
C521 HS_N HS_N_5 4.65354e-15
C522 HS_P HS_P_5 5.05127e-15
C523 FS_N_BLEED_2 PULLDOWN_P 7.40722e-17
C524 TERM_N_R TERM_GATE_P 1.39719e-15
C525 HS_P_6 HS_P_4 6.95596e-17
C526 VCM_LOW_OK PULLUP_P_BLEED_4 3.80972e-17
C527 RX_N DIV_P 3.75991e-16
C528 HS_N_4 HS_P_10 7.70625e-17
C529 PULLDOWN_P_R TERM_GATE_P_BLEED_0 1.24089e-16
C530 PULLUP_N_OUT PULLDOWN_P 7.84673e-17
C531 HS_P HS_P_8 3.0077e-15
C532 HS_N_12 TERM_VCM 1.20188e-16
C533 PULLDOWN_N_R PULLUP_P 5.76752e-17
C534 HS_N_5 FS_LOW_P 8.53302e-17
C535 HS_N_6 FS_P_BLEED_2 3.47206e-17
C536 PULLUP_N_OUT PAD_N 1.29226e-15
C537 FS_N_BLEED_1 FS_N_BLEED_0 1.54554e-15
C538 TERM_GATE_P HS_P_4 1.56269e-16
C539 PULLUP_N PULLUP_N_GATE 1.51486e-15
C540 HS_N_9 HS_P_2 3.08895e-17
C541 FS_N_BLEED_6 HS_P 4.81135e-17
C542 HS_P HS_P_7 5.33033e-16
C543 HS_N_8 HS_P_3 2.40376e-17
C544 TERM_P_R DIV_ENABLE 4.57093e-19
C545 HS_N HS_N_7 6.94187e-16
C546 PULLUP_P_BLEED_6 PULLUP_P_BLEED_4 1.53064e-18
C547 HS_P_6 TERM_GATE_P_BLEED_0 2.40376e-17
C548 FS_N_OUT FS_HIGH_P 9.98305e-17
C549 HS_PBIAS HS_N_0 5.90003e-15
C550 TERM_P_R PULLUP_N_BLEED_3 2.57363e-18
C551 PULLUP_N_BLEED_4 HS_P 2.11937e-18
C552 HS_N_6 HS_P_10 3.09658e-17
C553 PULLDOWN_N PULLDOWN_P 2.82816e-15
C554 DIV_ENABLE RX_P 8.82968e-16
C555 FS_P_OUT HS_P_12 1.09233e-16
C556 FS_N_OUT FS_P_BLEED_2 2.78894e-16
C557 FS_P_CONTROL_S FS_P_BLEED_0 4.29874e-17
C558 PULLUP_N_OUT PAD_P 1.11266e-16
C559 DIV_N FS_HIGH_P 8.52636e-15
C560 HS_N_9 TERM_GATE_N 5.60255e-17
C561 PULLDOWN_N_R FS_P_BLEED_0 1.01235e-16
C562 HS_N_2 TERM_VCM 1.23237e-16
C563 FS_P_WELL TERM_VCM 1.57773e-15
C564 PULLUP_N_GATE PULLUP_P 1.41779e-15
C565 HS_N_7 FS_LOW_P 8.55008e-17
C566 HS_N_8 FS_P_BLEED_2 3.47206e-17
C567 HS_N FS_N_BLEED_3 1.1535e-16
C568 TERM_P_R TERM_GATE_N_BLEED_0 1.06275e-16
C569 PULLUP_N PULLUP_N_BLEED_6 5.62374e-17
C570 PULLDOWN_N_R PULLUP_N_GATE 1.24845e-15
C571 FS_N_BLEED_1 FS_N_GATE 1.70709e-16
C572 DIV_N FS_P_BLEED_2 1.0151e-16
C573 TERM_VCM FS_P_BLEED_1 8.8022e-17
C574 TERM_GATE_P TERM_GATE_P_BLEED_0 4.84915e-15
C575 HS_N_9 TERM_OR_P_B 7.25438e-17
C576 PULLUP_P_BLEED_4 PULLUP_P_BLEED_5 6.36804e-15
C577 TERM_P_R HS_N_1 1.02275e-16
C578 HS_P HS_P_9 6.36218e-15
C579 HS_N DIV_ENABLE 5.80205e-17
C580 HS_PBIAS TERM_GATE_N_BLEED_1 4.82815e-17
C581 HS_N_10 HS_N_0 2.19009e-15
C582 PULLUP_P_GATE PULLUP_P_BLEED_4 2.77879e-16
C583 TERM_ENABLE HS_P_13 2.40376e-17
C584 HS_N_4 TERM_OR_P_NS 1.96068e-18
C585 PULLUP_P_BLEED_2 VCM_LOW_OK 1.46249e-17
C586 FS_P_GATE FS_P_OUT 1.35377e-13
C587 HS_N_8 HS_P_10 2.86027e-17
C588 HS_N PULLUP_N_BLEED_3 6.38681e-17
C589 HS_P_2 PULLUP_P_OUT 6.77322e-17
C590 TERM_OR_N_S PULLDOWN_P 1.27566e-16
C591 FS_P_OUT HS_P_5 5.46167e-17
C592 FS_N_BLEED_3 FS_LOW_P 1.03866e-16
C593 HS_P_3 VCM_LOW_OK 9.09648e-17
C594 FS_LOW_N TERM_GATE_N 9.03544e-17
C595 HS_N_4 TERM_VCM 1.2576e-16
C596 HS_N_11 TERM_GATE_N 4.85582e-17
C597 PULLDOWN_N_R HS_P_12 2.40376e-17
C598 DIV_ENABLE FS_LOW_P 1.08576e-16
C599 PULLUP_N_BLEED_6 PULLUP_P 1.07214e-16
C600 DIV_LOW_N HS_P 6.1779e-17
C601 TERM_P_R TERM_GATE_P_BLEED_1 2.57363e-18
C602 FS_HIGH_N TERM_ENABLE 1.51257e-17
C603 TERM_ENABLE HS_P_1 2.40376e-17
C604 PULLUP_N PULLUP_N_BLEED_5 8.99929e-17
C605 PULLDOWN_N_R PULLUP_N_BLEED_6 8.24271e-17
C606 HS_P HS_P_11 5.65023e-15
C607 HS_N_11 TERM_OR_P_B 7.338e-17
C608 PULLDOWN_P_R PULLUP_P_BLEED_4 5.46167e-17
C609 HS_N HS_N_1 3.90933e-15
C610 HS_N_10 TERM_GATE_N_BLEED_1 3.48887e-17
C611 HS_PBIAS TERM_GATE_N_BLEED_2 7.92848e-17
C612 HS_N_12 HS_N_0 3.94226e-17
C613 HS_N_6 TERM_OR_P_NS 3.50851e-18
C614 FS_P_GATE FS_P_CONTROL_S 1.43654e-15
C615 FS_P_BLEED_2 VCM_LOW_OK 3.80972e-17
C616 FS_HIGH_N BYPASS_ENABLE 1.04085e-19
C617 TERM_P_R PULLUP_N_BLEED_2 2.57363e-18
C618 TERM_OR_P_B PULLUP_P_OUT 1.99512e-16
C619 DIV_ENABLE RX_N 7.43703e-16
C620 VDD HS_P_2 5.70329e-15
C621 PULLDOWN_N_R FS_P_GATE 1.44476e-15
C622 FS_N_GATE TERM_N_R 8.17641e-16
C623 PULLUP_P_WELL FS_P_BLEED_3 6.74983e-19
C624 HS_N_13 TERM_GATE_N 4.80752e-17
C625 HS_N_6 TERM_VCM 1.30158e-16
C626 PULLDOWN_N_R HS_P_5 2.41139e-17
C627 HS_P_10 VCM_LOW_OK 9.04446e-17
C628 FS_N_BLEED_1 HS_P 9.67912e-17
C629 HS_N_1 FS_LOW_P 8.50523e-17
C630 PULLUP_N_BLEED_5 PULLUP_P 5.13203e-17
C631 TERM_P_R TERM_GATE_P_BLEED_2 6.55126e-17
C632 HS_PBIAS TERM_ENABLE 7.33359e-16
C633 PULLUP_N_GATE PULLUP_N_BLEED_6 3.03119e-15
C634 PULLUP_N PULLUP_N_BLEED_4 2.41042e-16
C635 PULLDOWN_N_R PULLUP_N_BLEED_5 4.9343e-17
C636 PULLUP_N_BLEED_0 PULLUP_N_BLEED_1 4.9716e-15
C637 HS_N_9 FS_P_BLEED_4 4.79044e-17
C638 HS_PBIAS FS_N_BLEED_5 8.85647e-17
C639 HS_N_13 TERM_OR_P_B 7.27112e-17
C640 FS_LOW_N TERM_OR_N_NS 7.06477e-16
C641 VDD TERM_GATE_N 5.37222e-15
C642 HS_N_12 TERM_GATE_N_BLEED_1 3.48887e-17
C643 HS_N_2 HS_N_0 3.92532e-17
C644 PULLDOWN_N_R HS_P_8 6.54378e-17
C645 HS_N_10 TERM_GATE_N_BLEED_2 5.26957e-17
C646 HS_N_8 TERM_OR_P_NS 7.03846e-18
C647 FS_P_WELL HS_N_0 2.67877e-15
C648 FS_P_GATE FS_P_BLEED_0 2.21834e-16
C649 PULLUP_P_BLEED_2 PULLUP_P_GATE 2.04956e-16
C650 PULLUP_N_BLEED_1 HS_P 4.82815e-17
C651 TERM_VCM FS_N_OUT 4.77098e-16
C652 HS_N PULLUP_N_BLEED_2 1.29428e-16
C653 FS_HIGH_N FS_N_CONTROL_S 5.89986e-15
C654 HS_N_0 FS_P_BLEED_1 6.1779e-17
C655 VDD TERM_OR_P_B 1.60128e-14
C656 FS_N_BLEED_6 PULLUP_P 5.44487e-17
C657 FS_HIGH_N DIFF_ENABLE 2.58323e-16
C658 HS_N_9 HS_P_13 5.49271e-17
C659 HS_N_3 TERM_GATE_N 4.80752e-17
C660 HS_N_8 TERM_VCM 1.76585e-16
C661 PULLDOWN_N_R HS_P_7 2.41789e-17
C662 FS_N_BLEED_6 PULLDOWN_N_R 4.81135e-17
C663 PULLUP_N_BLEED_4 PULLUP_P 2.0817e-19
C664 TERM_VCM DIV_N 7.23097e-16
C665 FS_N_WELL TERM_ENABLE 2.79697e-15
C666 FS_HIGH_P PULLUP_P_BLEED_5 3.57681e-17
C667 TERM_OR_P_B DIV_P 2.22993e-17
C668 HS_N_10 TERM_ENABLE 4.83462e-17
C669 FS_N_WELL FS_N_BLEED_5 1.63187e-19
C670 HS_N_11 FS_P_BLEED_4 2.90019e-17
C671 PULLUP_N_BLEED_0 TERM_N_R 1.14443e-16
C672 PULLUP_N_BLEED_2 FS_LOW_P 5.87202e-17
C673 PULLDOWN_N_R PULLUP_N_BLEED_4 8.99691e-17
C674 PULLUP_N_GATE PULLUP_N_BLEED_5 2.62715e-16
C675 FS_HIGH_P PULLUP_P_GATE 2.64516e-17
C676 HS_N_5 HS_P_2 3.08895e-17
C677 HS_N_3 TERM_OR_P_B 7.21128e-17
C678 HS_P HS_P_0 1.77665e-14
C679 PULLUP_N_OUT TERM_P_R 2.62394e-16
C680 PULLUP_P_BLEED_0 PULLUP_P_BLEED_4 2.57363e-18
C681 HS_N_2 TERM_GATE_N_BLEED_1 3.48887e-17
C682 HS_N_4 HS_N_0 3.91881e-17
C683 BYPASS_ENABLE FS_N_WELL 6.52469e-17
C684 PAD_N PAD_P 3.8984e-14
C685 HS_N_12 TERM_GATE_N_BLEED_2 5.26312e-17
C686 FS_P_GATE HS_P_12 5.99298e-18
C687 HS_PBIAS FS_N_CONTROL_S 9.19309e-17
C688 TERM_N_R HS_P 1.73336e-16
C689 FS_P_BLEED_2 PULLUP_P_GATE 4.48462e-18
C690 HS_N_9 HS_P_1 3.12002e-17
C691 HS_P_3 PULLDOWN_P_R 7.46551e-17
C692 HS_P_12 HS_P_5 3.88724e-17
C693 VDD TERM_OR_N_NS 3.0741e-16
C694 HS_N_11 HS_P_13 2.48708e-17
C695 VCM_LOW_OK TERM_OR_P_NS 2.92628e-15
C696 HS_PBIAS DIFF_ENABLE 1.71385e-16
C697 HS_N_5 TERM_GATE_N 5.06069e-17
C698 PULLDOWN_N_R HS_P_9 4.1634e-15
C699 FS_N_BLEED_6 PULLUP_N_GATE 5.48293e-18
C700 HS_N FS_N_BLEED_2 1.1535e-16
C701 HS_N_12 TERM_ENABLE 4.825e-17
C702 HS_P_8 HS_P_12 1.52593e-19
C703 HS_N_13 FS_P_BLEED_4 2.84614e-17
C704 PULLUP_N_GATE PULLUP_N_BLEED_4 1.03866e-16
C705 PULLUP_N_BLEED_6 PULLUP_N_BLEED_5 1.37599e-15
C706 HS_N_5 TERM_OR_P_B 7.21128e-17
C707 HS_P HS_P_4 1.7567e-15
C708 TERM_VCM VCM_LOW_OK 1.04222e-13
C709 HS_N_4 TERM_GATE_N_BLEED_1 3.48887e-17
C710 HS_N_2 TERM_GATE_N_BLEED_2 5.2499e-17
C711 HS_N_6 HS_N_0 3.91118e-17
C712 FS_HIGH_N FS_LOW_N 4.57398e-17
C713 PULLDOWN_N TERM_P_R 7.81167e-16
C714 PULLUP_N_OUT HS_N 1.08552e-16
C715 HS_P_3 HS_P_6 7.26076e-17
C716 FS_P_BLEED_2 PULLDOWN_P_R 5.44487e-17
C717 FS_N_CONTROL_S FS_N_WELL 7.19157e-16
C718 DIV_LOW_N PULLUP_P 4.81895e-17
C719 HS_PBIAS HS_N_9 3.54149e-15
C720 VDD FS_P_BLEED_4 2.57363e-18
C721 HS_P_12 HS_P_7 1.13762e-16
C722 FS_N_BLEED_2 FS_LOW_P 1.44632e-16
C723 PULLDOWN_N_R DIV_LOW_N 8.86788e-17
C724 HS_N_13 HS_P_13 2.45032e-17
C725 HS_N_7 TERM_GATE_N 5.24193e-17
C726 HS_P_10 PULLDOWN_P_R 7.46551e-17
C727 PULLDOWN_N_R HS_P_11 7.46551e-17
C728 HS_N_0 FS_N_OUT 6.16744e-17
C729 PULLUP_N_OUT FS_LOW_P 7.13152e-17
C730 HS_N_2 TERM_ENABLE 4.80752e-17
C731 HS_N_3 FS_P_BLEED_4 3.16784e-17
C732 FS_P_WELL TERM_ENABLE 2.59586e-15
C733 HS_P_8 HS_P_5 1.05682e-18
C734 PULLUP_N PULLUP_N_BLEED_1 5.49262e-16
C735 PULLUP_N_BLEED_6 PULLUP_N_BLEED_4 1.53063e-19
C736 FS_HIGH_P PULLUP_P_CONTROL_S 9.40947e-18
C737 HS_P_3 TERM_GATE_P 1.56594e-16
C738 HS_N_7 TERM_OR_P_B 7.21128e-17
C739 FS_HIGH_N FS_N_BLEED_4 1.52593e-19
C740 VDD HS_P_13 6.64852e-15
C741 HS_P TERM_GATE_P_BLEED_0 1.53654e-18
C742 TERM_ENABLE FS_P_BLEED_1 1.10378e-16
C743 TERM_P_R TERM_OR_N_S 3.05505e-16
C744 HS_N_6 TERM_GATE_N_BLEED_1 3.48887e-17
C745 HS_N_4 TERM_GATE_N_BLEED_2 5.2499e-17
C746 HS_N_8 HS_N_0 3.91118e-17
C747 HS_PBIAS FS_LOW_N 3.49326e-16
C748 HS_N_10 HS_N_9 4.45695e-17
C749 HS_PBIAS HS_N_11 1.09598e-15
C750 HS_N_0 DIV_N 4.09716e-17
C751 FS_P_WELL BYPASS_ENABLE 5.75902e-17
C752 HS_P_6 HS_P_10 7.64563e-17
C753 HS_P_5 HS_P_7 3.0785e-17
C754 FS_P_OUT HS_P_0 9.14594e-17
C755 TERM_P_R PULLUP_P_WELL 3.22671e-16
C756 HS_PBIAS PULLUP_P_OUT 5.0651e-16
C757 HS_N_3 HS_P_13 2.40376e-17
C758 DIV_ENABLE TERM_GATE_N 1.28396e-16
C759 TERM_N_R FS_P_OUT 3.85477e-16
C760 VDD FS_HIGH_N 5.856e-17
C761 PULLUP_P_BLEED_3 VCM_LOW_OK 1.56024e-16
C762 PULLUP_N_BLEED_1 PULLUP_P 5.74382e-17
C763 VDD HS_P_1 5.54122e-15
C764 HS_N_4 TERM_ENABLE 4.80752e-17
C765 TERM_GATE_N_BLEED_1 FS_N_OUT 6.16744e-17
C766 HS_N_5 FS_P_BLEED_4 3.39226e-17
C767 HS_P_8 HS_P_7 3.09838e-14
C768 PULLDOWN_N_R PULLUP_N_BLEED_1 4.84837e-17
C769 PULLUP_N TERM_N_R 2.24127e-16
C770 PULLUP_N_BLEED_5 PULLUP_N_BLEED_4 5.5147e-16
C771 HS_PBIAS FS_N_BLEED_4 8.85647e-17
C772 HS_N_1 HS_P_2 6.48683e-18
C773 DIV_ENABLE TERM_OR_P_B 6.06007e-19
C774 HS_N TERM_OR_N_S 1.12454e-16
C775 FS_LOW_N FS_N_WELL 1.02632e-15
C776 TERM_VCM PULLUP_P_GATE 1.69661e-16
C777 HS_N_8 TERM_GATE_N_BLEED_1 3.48887e-17
C778 HS_N_6 TERM_GATE_N_BLEED_2 5.2499e-17
C779 HS_N_10 FS_LOW_N 4.61521e-17
C780 HS_P_10 TERM_GATE_P 1.79029e-16
C781 HS_N_11 FS_N_WELL 1.99681e-17
C782 TERM_GATE_N_BLEED_1 DIV_N 1.0151e-16
C783 HS_N_12 HS_N_9 3.48887e-17
C784 HS_N_10 HS_N_11 1.37015e-13
C785 HS_PBIAS HS_N_13 4.9299e-15
C786 TERM_GATE_N TERM_GATE_N_BLEED_0 2.02705e-15
C787 HS_P_5 HS_P_9 6.21526e-19
C788 HS_P_12 HS_P_11 4.69655e-14
C789 TERM_P_R PULLDOWN_P 1.3388e-16
C790 PULLUP_P_BLEED_1 PULLUP_P_GATE 1.20989e-16
C791 HS_N PULLUP_P_WELL 4.25698e-16
C792 HS_N_0 VCM_LOW_OK 3.48887e-17
C793 HS_N_5 HS_P_13 5.49271e-17
C794 HS_N_10 PULLUP_P_OUT 2.54545e-17
C795 PULLDOWN_P_R TERM_OR_P_NS 5.65403e-17
C796 VDD HS_PBIAS 8.35191e-14
C797 VDD PULLUP_N_CONTROL_S 4.51526e-16
C798 HS_N_1 TERM_GATE_N 5.20551e-17
C799 PULLDOWN_N_R HS_P_0 3.03728e-17
C800 TERM_N_R PULLUP_P 5.05824e-16
C801 TERM_OR_N_S FS_LOW_P 8.19409e-17
C802 TERM_OR_P_S VCM_LOW_OK 1.87902e-15
C803 TERM_GATE_N_BLEED_2 FS_N_OUT 6.40782e-17
C804 HS_N_6 TERM_ENABLE 8.99634e-17
C805 HS_N_7 FS_P_BLEED_4 3.87195e-17
C806 PULLDOWN_N_R TERM_N_R 2.22554e-16
C807 HS_P_8 HS_P_9 3.03927e-14
C808 PULLUP_N_GATE PULLUP_N_BLEED_1 1.81408e-16
C809 HS_N_1 TERM_OR_P_B 7.4383e-17
C810 TERM_VCM PULLDOWN_P_R 2.23283e-16
C811 HS_N_8 TERM_GATE_N_BLEED_2 5.2499e-17
C812 FS_P_GATE HS_P_11 2.05397e-19
C813 PAD_N RX_P 1.67336e-15
C814 PULLUP_P_WELL FS_LOW_P 2.72232e-16
C815 HS_N_13 FS_N_WELL 2.09732e-17
C816 HS_N_12 FS_LOW_N 4.59909e-17
C817 HS_N_2 HS_N_9 2.0817e-19
C818 HS_N_10 HS_N_13 3.79438e-17
C819 HS_PBIAS HS_N_3 1.39899e-15
C820 HS_N_12 HS_N_11 1.36661e-13
C821 TERM_GATE_N_BLEED_2 DIV_N 6.00678e-19
C822 HS_P_6 TERM_OR_P_NS 2.84614e-17
C823 HS_N_5 HS_P_1 3.09658e-17
C824 FS_P_WELL HS_N_9 1.99234e-15
C825 PULLUP_P_BLEED_1 PULLDOWN_P_R 1.41333e-17
C826 HS_P_5 HS_P_11 3.88115e-17
C827 HS_P_7 HS_P_9 2.0615e-18
C828 HS_N_9 FS_P_BLEED_1 6.1779e-17
C829 TERM_P_R PAD_P 1.55448e-16
C830 PULLUP_P_BLEED_3 PULLUP_P_BLEED_5 3.06736e-19
C831 HS_N_12 PULLUP_P_OUT 2.4816e-17
C832 FS_N_OUT TERM_ENABLE 5.47642e-16
C833 HS_N_0 PULLUP_P_BLEED_6 2.49209e-17
C834 HS_N_7 HS_P_13 2.40376e-17
C835 VDD FS_N_WELL 1.36366e-13
C836 PULLDOWN_N_R HS_P_4 7.21687e-17
C837 PULLUP_P_BLEED_3 PULLUP_P_GATE 1.89537e-16
C838 HS_P PULLUP_P_BLEED_4 3.48887e-17
C839 TERM_N_R FS_P_BLEED_0 5.72918e-17
C840 FS_N_BLEED_0 FS_HIGH_P 1.40019e-17
C841 VDD HS_N_10 5.34851e-15
C842 TERM_VCM HS_P_6 9.61503e-17
C843 HS_N PAD_N 3.56371e-14
C844 TERM_OR_P_B TERM_GATE_P_BLEED_1 3.71e-18
C845 HS_N_8 TERM_ENABLE 1.0575e-16
C846 PAD_P RX_P 8.52519e-15
C847 PULLUP_N_GATE TERM_N_R 1.68546e-16
C848 HS_P_8 HS_P_11 7.92477e-18
C849 DIV_N TERM_ENABLE 1.34827e-18
C850 TERM_VCM PULLUP_P_CONTROL_S 3.42463e-17
C851 HS_N_2 FS_LOW_N 8.74721e-17
C852 HS_N FS_P_BLEED_3 1.43109e-17
C853 HS_N_2 HS_N_11 3.50404e-17
C854 HS_N_4 HS_N_9 3.26173e-17
C855 HS_N_10 HS_N_3 7.40917e-17
C856 FS_P_WELL HS_N_11 2.00581e-15
C857 HS_N_12 HS_N_13 1.35264e-13
C858 HS_PBIAS HS_N_5 2.62068e-15
C859 HS_N_7 HS_P_1 2.82661e-19
C860 BYPASS_ENABLE DIV_N 9.43608e-17
C861 TERM_VCM TERM_OR_N_B 2.4558e-17
C862 HS_P_12 HS_P_0 8.89903e-17
C863 HS_P_7 HS_P_11 9.63e-17
C864 HS_N_0 PULLUP_P_BLEED_5 5.2922e-17
C865 PULLUP_P_BLEED_1 PULLUP_P_CONTROL_S 5.13095e-19
C866 HS_N_11 FS_P_BLEED_1 6.1779e-17
C867 HS_N PAD_P 1.23865e-15
C868 TERM_VCM TERM_GATE_P 2.64481e-14
C869 HS_N_2 PULLUP_P_OUT 2.45088e-17
C870 HS_N_0 PULLUP_P_GATE 7.59445e-17
C871 FS_P_WELL PULLUP_P_OUT 3.18549e-15
C872 TERM_P_R DIV_LOW_P 1.06371e-18
C873 PULLDOWN_N_R TERM_GATE_P_BLEED_0 5.53044e-17
C874 VDD HS_N_12 6.63143e-15
C875 FS_N_GATE FS_HIGH_P 4.25584e-17
C876 FS_P_BLEED_1 PULLUP_P_OUT 1.10378e-16
C877 TERM_OR_P_B TERM_GATE_P_BLEED_2 3.48832e-18
C878 FS_P_BLEED_3 FS_LOW_P 7.81006e-17
C879 HS_N_1 FS_P_BLEED_4 2.93773e-17
C880 PULLUP_N_BLEED_6 TERM_N_R 5.72918e-17
C881 FS_N_OUT FS_N_CONTROL_S 4.18743e-17
C882 PULLUP_N_BLEED_5 PULLUP_N_BLEED_1 4.49448e-18
C883 FS_HIGH_N FS_N_BLEED_3 2.0817e-19
C884 PULLUP_N_OUT HS_P_2 7.96444e-17
C885 FS_N_BLEED_6 FS_N_BLEED_1 7.62796e-18
C886 HS_N_4 FS_LOW_N 4.57398e-17
C887 PAD_N RX_N 9.8031e-15
C888 HS_N_2 HS_N_13 1.25037e-13
C889 HS_N_4 HS_N_11 4.04393e-19
C890 HS_N_10 HS_N_5 2.0817e-19
C891 HS_N_6 HS_N_9 4.10107e-17
C892 FS_HIGH_N DIV_ENABLE 3.74927e-15
C893 HS_N_12 HS_N_3 6.41285e-17
C894 HS_PBIAS HS_N_7 7.23833e-15
C895 FS_P_WELL HS_N_13 1.9566e-15
C896 TERM_ENABLE VCM_LOW_OK 1.50477e-16
C897 TERM_N_R FS_P_GATE 7.54625e-16
C898 PULLUP_P_BLEED_1 PULLUP_P_BLEED_0 1.16396e-15
C899 HS_P_12 HS_P_4 6.21526e-19
C900 HS_N_13 FS_P_BLEED_1 6.1779e-17
C901 HS_P_5 HS_P_0 2.97357e-18
C902 HS_P_9 HS_P_11 8.16518e-18
C903 HS_N_0 FS_P_BLEED_6 6.1779e-17
C904 HS_N_4 PULLUP_P_OUT 2.40376e-17
C905 HS_N_0 PULLDOWN_P_R 2.50839e-17
C906 HS_N DIV_LOW_P 6.61104e-17
C907 HS_N_1 HS_P_13 1.21554e-16
C908 VDD HS_N_2 4.87598e-15
C909 FS_P_WELL VDD 1.30793e-13
C910 PULLUP_N_OUT TERM_GATE_N 2.7495e-16
C911 PAD_P RX_N 3.7917e-16
C912 FS_N_OUT HS_N_9 6.16744e-17
C913 PULLUP_N_BLEED_4 PULLUP_N_BLEED_1 6.85274e-19
C914 VDD FS_P_BLEED_1 6.21292e-16
C915 HS_PBIAS FS_N_BLEED_3 8.85647e-17
C916 PULLUP_N_OUT TERM_OR_P_B 2.07717e-16
C917 HS_P_3 HS_P 1.89056e-15
C918 HS_N_6 FS_LOW_N 4.57398e-17
C919 HS_N_4 HS_N_13 1.44632e-16
C920 HS_N_12 HS_N_5 4.04393e-19
C921 HS_N_6 HS_N_11 2.0817e-19
C922 HS_N_2 HS_N_3 1.22992e-13
C923 HS_N_10 HS_N_7 3.02657e-17
C924 HS_N_0 HS_P_6 6.11393e-17
C925 FS_P_WELL HS_N_3 1.91956e-15
C926 HS_N_8 HS_N_9 1.18342e-13
C927 PULLUP_N_WELL FS_N_BLEED_0 6.74983e-19
C928 HS_PBIAS DIV_ENABLE 6.11886e-17
C929 TERM_ENABLE PULLUP_P_BLEED_6 7.5456e-19
C930 DIV_LOW_P FS_LOW_P 1.25454e-16
C931 HS_N_9 DIV_N 3.31088e-17
C932 HS_N_1 HS_P_1 9.06571e-17
C933 HS_P_7 HS_P_0 4.6889e-18
C934 HS_P_5 HS_P_4 3.29896e-14
C935 HS_PBIAS PULLUP_N_BLEED_3 1.76792e-16
C936 HS_P_12 TERM_GATE_P_BLEED_0 3.63569e-17
C937 HS_N_3 FS_P_BLEED_1 6.1779e-17
C938 HS_N_6 PULLUP_P_OUT 2.40376e-17
C939 HS_N_0 PULLUP_P_CONTROL_S 3.48887e-17
C940 FS_N_BLEED_6 TERM_N_R 6.10527e-17
C941 VDD HS_N_4 5.65472e-15
C942 FS_P_BLEED_2 HS_P 3.47206e-17
C943 FS_LOW_N FS_N_OUT 3.14208e-16
C944 FS_N_WELL FS_N_BLEED_3 6.10284e-19
C945 HS_P_8 HS_P_4 3.12002e-17
C946 HS_N_0 TERM_OR_N_B 3.20569e-17
C947 FS_N_OUT HS_N_11 5.27536e-18
C948 HS_N_0 TERM_GATE_P 1.10833e-16
C949 PULLUP_P PULLUP_P_BLEED_4 2.24569e-16
C950 HS_N_8 FS_LOW_N 4.57398e-17
C951 DIV_ENABLE FS_N_WELL 2.67471e-16
C952 TERM_ENABLE PULLUP_P_BLEED_5 6.98984e-19
C953 FS_LOW_N DIV_N 3.54305e-17
C954 HS_N_2 HS_N_5 1.05682e-18
C955 HS_N_4 HS_N_3 1.22298e-13
C956 HS_N_6 HS_N_13 8.10079e-17
C957 HS_N_12 HS_N_7 2.95485e-17
C958 HS_P HS_P_10 2.44809e-15
C959 HS_PBIAS HS_N_1 9.60149e-15
C960 HS_N_10 DIV_ENABLE 3.18186e-17
C961 PULLDOWN_N_R PULLUP_P_BLEED_4 5.46167e-17
C962 HS_N_11 DIV_N 3.31088e-17
C963 FS_P_WELL HS_N_5 1.93199e-15
C964 TERM_ENABLE PULLUP_P_GATE 8.88041e-16
C965 HS_N_5 FS_P_BLEED_1 6.1779e-17
C966 HS_P_7 HS_P_4 6.06671e-17
C967 FS_HIGH_N PULLUP_N_BLEED_2 9.33261e-18
C968 HS_P_5 TERM_GATE_P_BLEED_0 2.4398e-17
C969 HS_N_8 PULLUP_P_OUT 2.40376e-17
C970 TERM_OR_N_S TERM_GATE_N 1.20685e-17
C971 HS_N_9 VCM_LOW_OK 3.62369e-17
C972 VDD HS_N_6 6.53266e-15
C973 FS_N_GATE TERM_VCM 1.09313e-15
C974 TERM_GATE_N_BLEED_1 TERM_OR_N_B 4.43349e-19
C975 HS_P_8 TERM_GATE_P_BLEED_0 2.71033e-17
C976 FS_N_OUT HS_N_13 5.51577e-18
C977 TERM_P_R HS_N 2.89261e-16
C978 TERM_ENABLE PULLDOWN_P_R 4.37656e-17
C979 HS_N_10 HS_N_1 1.24994e-13
C980 HS_N_6 HS_N_3 1.05682e-18
C981 HS_N_8 HS_N_13 5.62374e-17
C982 HS_N_2 HS_N_7 2.92558e-17
C983 FS_P_WELL HS_N_7 1.952e-15
C984 HS_N_4 HS_N_5 1.21885e-13
C985 TERM_ENABLE FS_P_BLEED_6 2.58247e-18
C986 HS_N_12 DIV_ENABLE 3.14337e-17
C987 HS_N_13 DIV_N 3.31088e-17
C988 VDD FS_N_OUT 1.19109e-14
C989 HS_P_7 TERM_GATE_P_BLEED_0 2.40376e-17
C990 HS_P_9 HS_P_4 4.19982e-17
C991 HS_PBIAS PULLUP_N_BLEED_2 7.92848e-17
C992 HS_P_11 HS_P_0 6.44472e-17
C993 HS_N_7 FS_P_BLEED_1 6.1779e-17
C994 HS_P_3 FS_P_OUT 9.14594e-17
C995 TERM_N_R DIV_LOW_N 3.0544e-16
C996 FS_LOW_N VCM_LOW_OK 7.42025e-17
C997 HS_N_11 VCM_LOW_OK 3.48887e-17
C998 TERM_N_R HS_P_11 5.72216e-17
C999 PULLUP_N_OUT HS_P_13 2.8681e-17
C1000 HS_N_9 PULLUP_P_BLEED_6 4.86947e-17
C1001 VDD HS_N_8 5.59181e-15
C1002 FS_N_OUT DIV_P 2.20134e-15
C1003 PAD_N HS_P_2 2.43754e-15
C1004 VDD DIV_N 4.45448e-16
C1005 TERM_P_R FS_LOW_P 2.50187e-16
C1006 PULLUP_N_WELL PULLUP_N_BLEED_0 2.56376e-15
C1007 FS_N_OUT HS_N_3 6.16744e-17
C1008 FS_HIGH_N FS_N_BLEED_2 2.82661e-19
C1009 FS_HIGH_P FS_P_OUT 1.12244e-16
C1010 TERM_GATE_N PULLDOWN_P 1.79027e-16
C1011 TERM_ENABLE HS_P_6 2.40376e-17
C1012 PULLUP_P_OUT VCM_LOW_OK 2.06785e-16
C1013 HS_N_0 FS_P_BLEED_5 6.1779e-17
C1014 TERM_OR_N_S TERM_OR_N_NS 1.63546e-17
C1015 PULLUP_N_WELL HS_P 2.91946e-16
C1016 HS_P TERM_OR_P_NS 4.05633e-17
C1017 DIV_N DIV_P 4.86079e-14
C1018 FS_P_BLEED_2 FS_P_OUT 3.04895e-18
C1019 PULLUP_P PULLUP_P_BLEED_2 1.44632e-16
C1020 HS_N_2 DIV_ENABLE 3.08895e-17
C1021 HS_N_12 HS_N_1 7.58432e-17
C1022 HS_N_8 HS_N_3 4.04393e-19
C1023 HS_N_6 HS_N_5 1.21169e-13
C1024 HS_N_4 HS_N_7 6.97616e-17
C1025 TERM_ENABLE PULLUP_P_CONTROL_S 5.71052e-17
C1026 PULLUP_N_OUT FS_HIGH_N 4.37656e-17
C1027 HS_N_3 DIV_N 3.35398e-17
C1028 FS_P_WELL DIV_ENABLE 9.4004e-17
C1029 TERM_VCM PULLUP_N_BLEED_0 1.34592e-16
C1030 HS_P_2 PAD_P 1.20139e-15
C1031 PULLUP_N_OUT HS_P_1 5.94742e-17
C1032 HS_P_11 HS_P_4 4.04393e-19
C1033 HS_P_9 TERM_GATE_P_BLEED_0 3.88758e-17
C1034 HS_N_9 PULLUP_P_BLEED_5 5.2499e-17
C1035 FS_LOW_N PULLUP_P_BLEED_6 8.29838e-17
C1036 TERM_VCM HS_P 2.3967e-16
C1037 TERM_ENABLE TERM_OR_N_B 3.87396e-16
C1038 HS_N_13 VCM_LOW_OK 3.48887e-17
C1039 HS_P_3 PULLDOWN_N_R 7.21687e-17
C1040 HS_N_11 PULLUP_P_BLEED_6 2.43374e-17
C1041 HS_N_9 PULLUP_P_GATE 7.72446e-17
C1042 TERM_ENABLE TERM_GATE_P 1.60491e-15
C1043 HS_N FS_LOW_P 1.00151e-16
C1044 RX_P RX_N 1.25825e-14
C1045 PULLUP_N_BLEED_1 TERM_N_R 6.10527e-17
C1046 HS_PBIAS FS_N_BLEED_2 9.92609e-17
C1047 FS_HIGH_P FS_P_CONTROL_S 4.75375e-16
C1048 VDD VCM_LOW_OK 5.76691e-14
C1049 FS_P_BLEED_2 FS_P_CONTROL_S 7.39879e-19
C1050 HS_N_4 DIV_ENABLE 3.08895e-17
C1051 PULLUP_N_OUT PULLUP_N_CONTROL_S 6.5761e-19
C1052 HS_N_2 HS_N_1 1.10911e-16
C1053 FS_P_WELL HS_N_1 2.0924e-15
C1054 HS_N_6 HS_N_7 1.19754e-13
C1055 HS_N_8 HS_N_5 4.89355e-17
C1056 PULLUP_N_OUT HS_PBIAS 8.01866e-16
C1057 PULLUP_P_WELL FS_P_BLEED_4 6.74983e-19
C1058 HS_N_5 DIV_N 3.31088e-17
C1059 PULLDOWN_N_R FS_P_BLEED_2 5.44487e-17
C1060 FS_LOW_N PULLUP_P_BLEED_5 8.29838e-17
C1061 HS_P_11 TERM_GATE_P_BLEED_0 3.68876e-17
C1062 HS_N_1 FS_P_BLEED_1 6.1779e-17
C1063 DIV_P VCM_LOW_OK 8.92332e-18
C1064 HS_N_11 PULLUP_P_BLEED_5 5.26622e-17
C1065 HS_N_9 PULLDOWN_P_R 2.40376e-17
C1066 HS_N_3 VCM_LOW_OK 3.48887e-17
C1067 HS_N_9 FS_P_BLEED_6 6.1779e-17
C1068 HS_N_13 PULLUP_P_BLEED_6 2.40376e-17
C1069 HS_N_11 PULLUP_P_GATE 7.36343e-17
C1070 FS_N_WELL FS_N_BLEED_2 1.07552e-18
C1071 PULLDOWN_N_R HS_P_10 7.46551e-17
C1072 FS_HIGH_P FS_P_BLEED_0 1.42453e-17
C1073 PULLUP_P_OUT PULLUP_P_GATE 1.83667e-14
C1074 PULLUP_N_GATE FS_HIGH_P 4.15499e-18
C1075 HS_N_6 DIV_ENABLE 3.08895e-17
C1076 HS_N_4 HS_N_1 4.30471e-17
C1077 HS_N_8 HS_N_7 1.19047e-13
C1078 PULLUP_N_OUT FS_N_WELL 2.29376e-15
C1079 FS_P_BLEED_2 FS_P_BLEED_0 8.54567e-18
C1080 HS_N_7 DIV_N 3.31088e-17
C1081 HS_N_9 HS_P_6 5.49271e-17
C1082 HS_P_3 HS_P_12 2.89898e-17
C1083 HS_P_0 HS_P_4 2.18985e-18
C1084 HS_N_13 PULLUP_P_BLEED_5 5.2499e-17
C1085 FS_LOW_N PULLDOWN_P_R 8.6398e-18
C1086 HS_N_11 FS_P_BLEED_6 6.1779e-17
C1087 TERM_N_R HS_P_4 5.72216e-17
C1088 HS_N_9 PULLUP_P_CONTROL_S 3.48887e-17
C1089 HS_N_13 PULLUP_P_GATE 7.27112e-17
C1090 HS_N_3 PULLUP_P_BLEED_6 2.79501e-17
C1091 HS_N_11 PULLDOWN_P_R 2.4295e-17
C1092 HS_N_5 VCM_LOW_OK 3.5346e-17
C1093 PULLUP_N_WELL PULLUP_N 1.16079e-16
C1094 FS_N_OUT DIV_ENABLE 1.53763e-16
C1095 PULLUP_P_OUT PULLDOWN_P_R 1.04805e-16
C1096 FS_P_BLEED_3 FS_P_BLEED_4 4.60809e-16
C1097 PULLUP_P_OUT FS_P_BLEED_6 5.12704e-17
C1098 TERM_VCM FS_P_OUT 3.86377e-16
C1099 HS_N_9 TERM_OR_N_B 2.88924e-17
C1100 VDD PULLUP_P_GATE 1.65757e-14
C1101 HS_N_0 HS_P 1.61812e-16
C1102 FS_N_BLEED_0 FS_N_BLEED_5 1.05416e-16
C1103 HS_N_9 TERM_GATE_P 1.36047e-16
C1104 HS_N_8 DIV_ENABLE 3.08895e-17
C1105 HS_N_6 HS_N_1 4.2943e-17
C1106 HS_PBIAS TERM_OR_N_S 1.86419e-16
C1107 PULLUP_N_OUT HS_N_12 1.36783e-17
C1108 HS_N_11 HS_P_6 5.93224e-17
C1109 PAD_N HS_P_13 1.69383e-16
C1110 DIV_ENABLE DIV_N 3.30014e-14
C1111 HS_P_0 TERM_GATE_P_BLEED_0 5.91203e-18
C1112 HS_P_3 HS_P_5 3.19202e-17
C1113 HS_N_3 PULLUP_P_BLEED_5 5.2499e-17
C1114 FS_HIGH_N PULLDOWN_P 3.74305e-17
C1115 PULLUP_N_WELL PULLUP_P 8.30565e-15
C1116 HS_N_13 PULLDOWN_P_R 2.40376e-17
C1117 TERM_N_R TERM_GATE_P_BLEED_0 1.44632e-16
C1118 HS_N_13 FS_P_BLEED_6 6.1779e-17
C1119 HS_N_11 PULLUP_P_CONTROL_S 3.48887e-17
C1120 HS_N_3 PULLUP_P_GATE 7.21128e-17
C1121 HS_N_7 VCM_LOW_OK 3.56562e-17
C1122 HS_N_5 PULLUP_P_BLEED_6 3.06896e-17
C1123 HS_PBIAS PULLUP_P_WELL 5.89791e-16
C1124 HS_N_9 PULLUP_P_BLEED_0 1.05304e-18
C1125 HS_P_10 HS_P_12 7.58948e-17
C1126 FS_P_GATE FS_HIGH_P 4.36344e-16
C1127 PULLUP_N_WELL PULLDOWN_N_R 3.20503e-16
C1128 PULLDOWN_N_R TERM_OR_P_NS 4.59148e-17
C1129 HS_P_3 HS_P_8 3.10917e-17
C1130 FS_LOW_N TERM_OR_N_B 1.10292e-15
C1131 FS_P_BLEED_2 FS_P_GATE 2.00085e-16
C1132 HS_N_11 TERM_OR_N_B 2.97776e-17
C1133 PAD_P HS_P_13 1.35247e-15
C1134 PULLUP_P_OUT PULLUP_P_CONTROL_S 1.1774e-17
C1135 FS_N_GATE TERM_ENABLE 1.09657e-15
C1136 VDD FS_P_BLEED_6 1.1762e-18
C1137 TERM_VCM PULLUP_P 2.42866e-16
C1138 TERM_P_R HS_P_2 8.49117e-17
C1139 PAD_N HS_P_1 5.67079e-16
C1140 VDD PULLDOWN_P_R 1.96881e-15
C1141 HS_N_11 TERM_GATE_P 1.08523e-16
C1142 TERM_GATE_N_BLEED_1 HS_P 3.48887e-17
C1143 FS_N_GATE FS_N_BLEED_5 2.50046e-16
C1144 HS_N_10 TERM_OR_N_S 6.33501e-17
C1145 HS_N_8 HS_N_1 4.2943e-17
C1146 TERM_VCM PULLDOWN_N_R 3.58985e-16
C1147 FS_P_WELL PULLUP_N_OUT 2.65152e-15
C1148 HS_N_1 DIV_N 3.45142e-17
C1149 HS_N_13 HS_P_6 5.88824e-17
C1150 PULLUP_P PULLUP_P_BLEED_1 2.71448e-16
C1151 HS_P_3 HS_P_7 6.11551e-17
C1152 PULLUP_P_OUT TERM_GATE_P 4.0537e-16
C1153 HS_P_4 TERM_GATE_P_BLEED_0 2.45087e-17
C1154 PULLUP_N_OUT FS_P_BLEED_1 1.1535e-16
C1155 HS_N_5 PULLUP_P_BLEED_5 5.2499e-17
C1156 PULLUP_N_CONTROL_S PULLDOWN_P 3.06486e-17
C1157 HS_N_3 FS_P_BLEED_6 6.1779e-17
C1158 HS_N_10 PULLUP_P_WELL 2.16705e-16
C1159 HS_PBIAS PULLDOWN_P 4.38779e-16
C1160 PULLDOWN_N_R PULLUP_P_BLEED_1 1.94556e-18
C1161 HS_N_3 PULLDOWN_P_R 2.40376e-17
C1162 HS_P_10 HS_P_5 4.80989e-17
C1163 HS_N_13 PULLUP_P_CONTROL_S 3.48887e-17
C1164 TERM_P_R TERM_GATE_N 1.48725e-16
C1165 HS_N_7 PULLUP_P_BLEED_6 3.66315e-17
C1166 HS_N_5 PULLUP_P_GATE 7.37624e-17
C1167 PAD_P HS_P_1 1.23389e-15
C1168 VDD HS_P_6 6.8233e-15
C1169 PULLUP_N_WELL PULLUP_N_GATE 3.63413e-14
C1170 FS_N_BLEED_6 FS_HIGH_P 9.40718e-17
C1171 TERM_P_R TERM_OR_P_B 7.68571e-16
C1172 HS_N_13 TERM_OR_N_B 2.92151e-17
C1173 HS_N HS_P_2 4.63517e-16
C1174 VDD PULLUP_P_CONTROL_S 7.26698e-15
C1175 TERM_VCM FS_P_BLEED_0 1.88962e-17
C1176 TERM_GATE_N_BLEED_2 HS_P 5.2499e-17
C1177 HS_N_13 TERM_GATE_P 1.076e-16
C1178 HS_P_6 DIV_P 3.38809e-17
C1179 HS_P_8 HS_P_10 9.26191e-18
C1180 FS_P_BLEED_5 HS_N_9 6.29519e-17
C1181 HS_N_12 TERM_OR_N_S 6.33501e-17
C1182 PULLUP_N_OUT HS_N_4 2.97726e-18
C1183 TERM_VCM PULLUP_N_GATE 2.53557e-16
C1184 HS_N_3 HS_P_6 5.82839e-17
C1185 FS_N_GATE FS_N_CONTROL_S 3.06729e-15
C1186 VDD TERM_OR_N_B 1.4119e-14
C1187 VCM_LOW_OK TERM_GATE_N_BLEED_0 8.40177e-17
C1188 HS_P_3 HS_P_9 4.19373e-17
C1189 HS_N_7 PULLUP_P_BLEED_5 5.2499e-17
C1190 PULLUP_N_BLEED_0 TERM_ENABLE 1.1535e-16
C1191 FS_N_WELL PULLDOWN_P 2.85309e-15
C1192 VDD TERM_GATE_P 7.09843e-15
C1193 HS_P_12 TERM_OR_P_NS 3.93125e-17
C1194 HS_N_0 FS_P_OUT 5.60895e-16
C1195 HS_N_5 PULLDOWN_P_R 2.40376e-17
C1196 HS_N_1 VCM_LOW_OK 3.48887e-17
C1197 HS_N_5 FS_P_BLEED_6 6.1779e-17
C1198 HS_N_3 PULLUP_P_CONTROL_S 3.48887e-17
C1199 HS_N_12 PULLUP_P_WELL 1.93659e-16
C1200 HS_N TERM_GATE_N 8.6863e-17
C1201 HS_N_7 PULLUP_P_GATE 7.49248e-17
C1202 PULLUP_P_BLEED_3 PULLUP_P 1.03866e-16
C1203 HS_P_10 HS_P_7 1.06828e-16
C1204 HS_P_2 FS_LOW_P 4.61847e-17
C1205 TERM_ENABLE HS_P 5.44104e-17
C1206 FS_N_BLEED_5 HS_P 8.85647e-17
C1207 PAD_N HS_N_10 1.35483e-15
C1208 DIV_P TERM_GATE_P 2.27442e-17
C1209 HS_N_3 TERM_OR_N_B 2.84614e-17
C1210 TERM_VCM HS_P_12 1.07001e-16
C1211 HS_N_3 TERM_GATE_P 1.11035e-16
C1212 VDD PULLUP_P_BLEED_0 4.79522e-18
C1213 HS_N TERM_OR_P_B 1.31105e-16
C1214 FS_P_BLEED_5 HS_N_11 6.1779e-17
C1215 TERM_P_R TERM_OR_N_NS 1.7892e-16
C1216 HS_N_2 TERM_OR_N_S 6.33501e-17
C1217 TERM_N_R PULLUP_P_BLEED_4 6.10527e-17
C1218 PULLUP_N_OUT HS_N_6 4.91368e-17
C1219 TERM_VCM PULLUP_N_BLEED_6 2.04122e-17
C1220 FS_N_BLEED_0 FS_LOW_N 8.4917e-17
C1221 TERM_GATE_N FS_LOW_P 4.93931e-17
C1222 HS_N_10 FS_P_BLEED_3 1.96739e-19
C1223 HS_N_5 HS_P_6 5.82839e-17
C1224 FS_N_GATE HS_N_9 2.25616e-18
C1225 HS_P_3 HS_P_11 2.87722e-17
C1226 HS_N_0 FS_P_CONTROL_S 3.29554e-17
C1227 DIV_ENABLE PULLUP_P_BLEED_5 2.67272e-19
C1228 HS_P_5 TERM_OR_P_NS 2.84614e-17
C1229 HS_N_7 FS_P_BLEED_6 6.1779e-17
C1230 HS_N_0 PULLUP_P 5.06175e-17
C1231 HS_N_12 PULLDOWN_P 5.19379e-17
C1232 HS_N_2 PULLUP_P_WELL 1.77836e-16
C1233 HS_N_10 PAD_P 1.19493e-16
C1234 HS_N_7 PULLDOWN_P_R 2.40376e-17
C1235 HS_N_5 PULLUP_P_CONTROL_S 3.48887e-17
C1236 HS_P_10 HS_P_9 8.86842e-18
C1237 HS_N_1 PULLUP_P_BLEED_6 2.45138e-17
C1238 DIV_ENABLE PULLUP_P_GATE 6.06007e-19
C1239 DIV_LOW_N FS_HIGH_P 1.65342e-16
C1240 TERM_VCM FS_P_GATE 6.24859e-16
C1241 TERM_OR_P_B FS_LOW_P 1.1369e-15
C1242 HS_N_0 PULLDOWN_N_R 6.83199e-17
C1243 HS_PBIAS DIV_LOW_P 6.13173e-19
C1244 FS_P_BLEED_1 PULLUP_P_WELL 6.74983e-19
C1245 PULLUP_N_OUT FS_N_OUT 5.13997e-16
C1246 PAD_N HS_N_12 1.21768e-15
C1247 HS_P_8 TERM_OR_P_NS 2.84614e-17
C1248 TERM_VCM HS_P_5 9.61503e-17
C1249 HS_N_5 TERM_OR_N_B 2.84614e-17
C1250 FS_N_BLEED_0 FS_N_BLEED_4 1.22122e-16
C1251 HS_N_5 TERM_GATE_P 1.15021e-16
C1252 FS_P_BLEED_5 HS_N_13 6.1779e-17
C1253 FS_N_CONTROL_S HS_P 9.19309e-17
C1254 HS_N_4 TERM_OR_N_S 6.53108e-17
C1255 PULLUP_N_OUT HS_N_8 6.1286e-17
C1256 FS_N_GATE FS_LOW_N 7.35085e-16
C1257 HS_N_7 HS_P_6 2.53634e-17
C1258 HS_N_12 FS_P_BLEED_3 1.32245e-19
C1259 FS_N_GATE HS_N_11 1.48783e-17
C1260 VCM_LOW_OK TERM_GATE_P_BLEED_2 1.42923e-17
C1261 PULLUP_N_OUT DIV_N 4.44725e-19
C1262 TERM_VCM HS_P_8 9.67122e-17
C1263 HS_N_1 PULLUP_P_BLEED_5 5.28587e-17
C1264 HS_P_7 TERM_OR_P_NS 2.84614e-17
C1265 HS_N_0 FS_P_BLEED_0 6.1779e-17
C1266 TERM_GATE_N_BLEED_1 PULLUP_P 5.46167e-17
C1267 HS_P DIFF_ENABLE 1.65095e-16
C1268 PULLUP_N_WELL FS_N_BLEED_6 2.16428e-17
C1269 VDD FS_P_BLEED_5 2.57363e-18
C1270 HS_N_7 PULLUP_P_CONTROL_S 3.48887e-17
C1271 FS_N_BLEED_1 FS_HIGH_P 6.21526e-19
C1272 TERM_P_R HS_P_13 8.55358e-17
C1273 HS_N_4 PULLUP_P_WELL 1.83709e-16
C1274 HS_N_12 PAD_P 2.18792e-15
C1275 HS_N_5 PULLUP_P_BLEED_0 3.33636e-19
C1276 HS_N_1 PULLUP_P_GATE 7.48502e-17
C1277 HS_P_10 HS_P_11 4.83384e-14
C1278 TERM_GATE_N_BLEED_1 PULLDOWN_N_R 4.82815e-17
C1279 VDD FS_N_BLEED_0 3.14506e-19
C1280 HS_N_10 DIV_LOW_P 2.59079e-18
C1281 PAD_N HS_N_2 1.16258e-15
C1282 HS_N FS_P_BLEED_4 4.62963e-17
C1283 HS_N_7 TERM_OR_N_B 2.84614e-17
C1284 TERM_VCM HS_P_7 9.61503e-17
C1285 FS_N_BLEED_6 TERM_VCM 4.26329e-17
C1286 HS_N_7 TERM_GATE_P 1.21977e-16
C1287 FS_P_BLEED_5 HS_N_3 6.1779e-17
C1288 FS_N_GATE FS_N_BLEED_4 2.13148e-16
C1289 PULLUP_N_BLEED_1 FS_HIGH_P 9.40038e-17
C1290 HS_N_6 TERM_OR_N_S 6.68586e-17
C1291 HS_N_9 HS_P 1.20311e-13
C1292 TERM_P_R FS_HIGH_N 7.19183e-18
C1293 TERM_ENABLE FS_P_OUT 5.4337e-16
C1294 TERM_P_R HS_P_1 1.02485e-16
C1295 FS_N_GATE HS_N_13 1.99454e-16
C1296 FS_P_WELL FS_P_BLEED_3 6.01861e-18
C1297 HS_P_3 HS_P_0 3.77193e-17
C1298 TERM_N_R PULLUP_P_BLEED_2 5.72918e-17
C1299 FS_P_BLEED_1 FS_P_BLEED_3 3.06736e-19
C1300 HS_N_0 HS_P_12 7.54702e-17
C1301 HS_P_9 TERM_OR_P_NS 3.93679e-17
C1302 HS_N_1 FS_P_BLEED_6 6.1779e-17
C1303 TERM_GATE_N_BLEED_2 PULLUP_P 9.19551e-17
C1304 HS_N_2 PAD_P 1.25659e-15
C1305 HS_N_6 PULLUP_P_WELL 1.84121e-16
C1306 HS_P_3 TERM_N_R 5.03697e-17
C1307 HS_N HS_P_13 3.53743e-16
C1308 HS_N_1 PULLDOWN_P_R 2.44546e-17
C1309 HS_N_7 PULLUP_P_BLEED_0 5.67482e-19
C1310 TERM_GATE_N_BLEED_2 PULLDOWN_N_R 7.92848e-17
C1311 PULLUP_N_OUT VCM_LOW_OK 1.5823e-16
C1312 HS_N_12 DIV_LOW_P 1.35539e-18
C1313 VDD FS_N_GATE 2.72268e-14
C1314 FS_N_OUT TERM_OR_N_S 6.83005e-17
C1315 PAD_N HS_N_4 1.29614e-15
C1316 TERM_VCM HS_P_9 1.40495e-16
C1317 FS_LOW_N HS_P 4.57398e-17
C1318 DIV_ENABLE TERM_GATE_P 4.32213e-18
C1319 TERM_N_R FS_HIGH_P 9.47315e-17
C1320 HS_N_11 HS_P 7.64555e-16
C1321 FS_P_BLEED_5 HS_N_5 6.21895e-17
C1322 HS_N FS_HIGH_N 5.08233e-17
C1323 FS_N_OUT PULLUP_P_WELL 1.44465e-16
C1324 HS_N_8 TERM_OR_N_S 7.03885e-17
C1325 TERM_P_R HS_PBIAS 5.42172e-16
C1326 HS_N_0 FS_P_GATE 1.01462e-15
C1327 TERM_ENABLE PULLUP_P 9.05208e-17
C1328 TERM_OR_N_S DIV_N 4.31015e-19
C1329 HS_N_1 HS_P_6 6.02318e-17
C1330 HS_P_13 FS_LOW_P 4.60078e-17
C1331 TERM_N_R FS_P_BLEED_2 6.10527e-17
C1332 PULLUP_P FS_N_BLEED_5 1.01235e-16
C1333 HS_N HS_P_1 7.50074e-16
C1334 PULLDOWN_P_R TERM_GATE_P_BLEED_1 1.41333e-17
C1335 PULLDOWN_N_R TERM_ENABLE 1.36385e-16
C1336 HS_P_3 HS_P_4 3.36448e-14
C1337 HS_N_0 HS_P_5 3.48887e-17
C1338 HS_P PULLUP_P_OUT 2.40376e-17
C1339 HS_N_6 PULLDOWN_P 4.42824e-17
C1340 HS_P_11 TERM_OR_P_NS 4.28516e-17
C1341 HS_N_1 PULLUP_P_CONTROL_S 3.48887e-17
C1342 PULLDOWN_N_R FS_N_BLEED_5 8.85647e-17
C1343 HS_N_4 PAD_P 6.51672e-17
C1344 HS_N_8 PULLUP_P_WELL 1.98765e-16
C1345 PULLUP_N_OUT PULLUP_P_BLEED_6 9.19551e-17
C1346 HS_P_10 HS_P_0 2.2381e-15
C1347 DIV_N PULLUP_P_WELL 8.03831e-17
C1348 HS_N_2 DIV_LOW_P 8.03819e-19
C1349 TERM_OR_N_B TERM_GATE_N_BLEED_0 4.76897e-18
C1350 TERM_VCM DIV_LOW_N 3.29961e-16
C1351 TERM_N_R HS_P_10 5.03697e-17
C1352 FS_N_BLEED_4 HS_P 8.85647e-17
C1353 PAD_N HS_N_6 1.1595e-15
C1354 FS_HIGH_N FS_LOW_P 5.90964e-17
C1355 HS_N_1 TERM_OR_N_B 3.09551e-17
C1356 TERM_VCM HS_P_11 1.3824e-16
C1357 HS_P_1 FS_LOW_P 1.12624e-16
C1358 HS_N_1 TERM_GATE_P 1.09739e-16
C1359 FS_P_BLEED_5 HS_N_7 6.24551e-17
C1360 FS_N_OUT PULLDOWN_P 6.14403e-16
C1361 HS_N_13 HS_P 1.05194e-16
C1362 TERM_P_R FS_N_WELL 1.52918e-15
C1363 PULLUP_N DIFF_ENABLE 1.3679e-16
C1364 PULLUP_N_WELL FS_N_BLEED_1 6.74983e-19
C1365 TERM_P_R HS_N_10 6.03432e-17
C1366 VDD PULLUP_N_BLEED_0 7.77842e-16
C1367 HS_N HS_PBIAS 3.96706e-16
C1368 TERM_ENABLE FS_P_BLEED_0 8.07085e-17
C1369 HS_P_3 TERM_GATE_P_BLEED_0 2.46413e-17
C1370 PULLUP_N_GATE TERM_ENABLE 2.30355e-16
C1371 PULLUP_N_OUT PULLUP_P_BLEED_5 9.19551e-17
C1372 HS_N_8 PULLDOWN_P 4.42824e-17
C1373 HS_N_6 PAD_P 2.14046e-15
C1374 PAD_N FS_N_OUT 4.10443e-15
C1375 PULLUP_N_GATE FS_N_BLEED_5 4.58337e-19
C1376 VDD HS_P 1.70325e-15
C1377 HS_P_10 HS_P_4 2.82661e-19
C1378 FS_N_CONTROL_S PULLUP_P 1.04601e-16
C1379 HS_N_9 FS_P_OUT 4.33772e-16
C1380 DIV_N PULLDOWN_P 4.61315e-17
C1381 TERM_OR_N_S VCM_LOW_OK 4.63203e-15
C1382 PULLUP_N_WELL PULLUP_N_BLEED_1 8.20771e-17
C1383 PULLUP_N_OUT PULLUP_P_GATE 2.9848e-16
C1384 PULLDOWN_N_R FS_N_CONTROL_S 9.19309e-17
C1385 TERM_GATE_P TERM_GATE_P_BLEED_1 3.76164e-16
C1386 HS_P_2 TERM_OR_P_B 1.03068e-16
C1387 FS_N_OUT FS_P_BLEED_3 1.39258e-16
C1388 PAD_N HS_N_8 1.07245e-15
C1389 HS_PBIAS FS_LOW_P 3.43558e-16
C1390 PULLUP_P DIFF_ENABLE 6.60983e-17
C1391 PULLUP_P_WELL VCM_LOW_OK 3.19257e-16
C1392 HS_P DIV_P 8.00466e-17
C1393 PAD_N DIV_N 6.88592e-16
C1394 FS_N_BLEED_0 FS_N_BLEED_3 1.187e-16
C1395 HS_N FS_N_WELL 5.1841e-15
C1396 HS_N_3 HS_P 1.78669e-16
C1397 PULLDOWN_N_R DIFF_ENABLE 1.83335e-19
C1398 TERM_ENABLE HS_P_12 2.40376e-17
C1399 TERM_VCM PULLUP_N_BLEED_1 4.26329e-17
C1400 TERM_P_R HS_N_12 5.97047e-17
C1401 FS_N_OUT PAD_P 1.79266e-16
C1402 HS_N HS_N_10 3.84913e-15
C1403 FS_N_BLEED_0 DIV_ENABLE 2.67272e-19
C1404 DIV_N FS_P_BLEED_3 6.00678e-19
C1405 PULLUP_N_BLEED_6 TERM_ENABLE 8.9543e-17
C1406 HS_P_0 TERM_OR_P_NS 7.62118e-17
C1407 HS_N_9 FS_P_CONTROL_S 3.24151e-17
C1408 HS_N_11 FS_P_OUT 4.39756e-16
C1409 HS_N_8 PAD_P 4.35222e-16
C1410 TERM_OR_N_S PULLUP_P_BLEED_6 2.57363e-18
C1411 PULLUP_N_OUT PULLDOWN_P_R 6.25611e-17
C1412 DIV_N PAD_P 4.53665e-16
C1413 PULLUP_N_OUT FS_P_BLEED_6 5.92219e-17
C1414 HS_P_10 TERM_GATE_P_BLEED_0 3.77659e-17
C1415 PULLUP_N_WELL TERM_N_R 2.84306e-16
C1416 PULLDOWN_N_R HS_N_9 2.40376e-17
C1417 TERM_N_R TERM_OR_P_NS 1.01098e-16
C1418 TERM_GATE_P TERM_GATE_P_BLEED_2 4.03441e-16
C1419 FS_N_WELL FS_LOW_P 1.62691e-15
C1420 PULLUP_P_OUT FS_P_OUT 5.75658e-16
C1421 HS_N_10 FS_LOW_P 8.50523e-17
C1422 PULLDOWN_P VCM_LOW_OK 3.74305e-17
C1423 TERM_ENABLE FS_P_GATE 1.01177e-15
C1424 TERM_VCM HS_P_0 1.95366e-16
C1425 FS_P_BLEED_5 HS_N_1 6.1779e-17
C1426 FS_N_GATE FS_N_BLEED_3 1.92602e-16
C1427 TERM_ENABLE HS_P_5 2.40376e-17
C1428 HS_N_5 HS_P 8.71868e-16
C1429 TERM_P_R HS_N_2 5.93974e-17
C1430 FS_P_WELL TERM_P_R 1.45352e-15
C1431 TERM_VCM TERM_N_R 1.74845e-14
C1432 HS_N HS_N_12 8.83112e-15
C1433 HS_N_0 DIV_LOW_N 6.94888e-17
C1434 FS_N_GATE DIV_ENABLE 4.50932e-18
C1435 PULLUP_N_OUT HS_P_6 2.84614e-17
C1436 FS_N_OUT DIV_LOW_P 5.52472e-17
C1437 PULLUP_N_BLEED_5 TERM_ENABLE 1.16848e-17
C1438 TERM_OR_N_S PULLUP_P_BLEED_5 2.57363e-18
C1439 TERM_P_R FS_P_BLEED_1 1.09344e-16
C1440 HS_P_4 TERM_OR_P_NS 2.84614e-17
C1441 FS_LOW_N PULLUP_P 6.42575e-17
C1442 HS_N_11 FS_P_CONTROL_S 3.23362e-17
C1443 HS_N_9 FS_P_BLEED_0 6.1779e-17
C1444 HS_N_13 FS_P_OUT 5.28226e-16
C1445 TERM_ENABLE HS_P_8 2.40376e-17
C1446 PULLUP_N_OUT PULLUP_P_CONTROL_S 5.46167e-17
C1447 FS_LOW_N PULLDOWN_N_R 5.91326e-17
C1448 PULLUP_P_BLEED_2 PULLUP_P_BLEED_4 8.54567e-18
C1449 PULLDOWN_N_R HS_N_11 2.40376e-17
C1450 PULLUP_P_WELL PULLUP_P_BLEED_5 5.4639e-19
C1451 DIV_N DIV_LOW_P 8.93453e-16
C1452 HS_N_12 FS_LOW_P 8.50523e-17
C1453 PULLUP_P PULLUP_P_OUT 5.45617e-18
C1454 PULLDOWN_P PULLUP_P_BLEED_6 5.12217e-18
C1455 TERM_VCM HS_P_4 1.24612e-16
C1456 VDD FS_P_OUT 1.10126e-14
C1457 PAD_P VCM_LOW_OK 4.75972e-18
C1458 PULLUP_P_WELL PULLUP_P_GATE 3.58752e-14
C1459 PULLUP_N_OUT TERM_OR_N_B 1.37687e-16
C1460 HS_N_7 HS_P 3.34579e-16
C1461 PULLDOWN_N_R PULLUP_P_OUT 4.9012e-17
C1462 PULLUP_N_OUT TERM_GATE_P 3.7427e-16
C1463 TERM_ENABLE HS_P_7 2.40376e-17
C1464 TERM_P_R HS_N_4 5.89263e-17
C1465 FS_N_BLEED_6 TERM_ENABLE 6.15064e-17
C1466 HS_N HS_N_2 6.79185e-15
C1467 VDD PULLUP_N 1.61919e-17
C1468 FS_P_WELL HS_N 4.10032e-14
C1469 PULLUP_P FS_N_BLEED_4 1.01235e-16
C1470 DIV_P FS_P_OUT 1.27896e-17
C1471 FS_N_BLEED_6 FS_N_BLEED_5 9.22595e-15
C1472 HS_N FS_P_BLEED_1 8.04284e-17
C1473 HS_P_2 HS_P_13 3.6317e-14
C1474 FS_HIGH_P PULLUP_P_BLEED_4 1.64407e-16
C1475 HS_N_9 HS_P_12 6.57781e-17
C1476 HS_N_3 FS_P_OUT 4.87923e-16
C1477 HS_N_13 FS_P_CONTROL_S 3.22599e-17
C1478 HS_N_11 FS_P_BLEED_0 6.1779e-17
C1479 PULLDOWN_N_R FS_N_BLEED_4 8.85647e-17
C1480 FS_N_BLEED_6 BYPASS_ENABLE 7.65665e-18
C1481 HS_N_13 PULLUP_P 4.37656e-17
C1482 PULLUP_N_OUT PULLUP_P_BLEED_0 9.26796e-17
C1483 FS_LOW_N PULLUP_N_GATE 9.32886e-17
C1484 TERM_N_R PULLUP_P_BLEED_3 1.14443e-16
C1485 PULLDOWN_N_R HS_N_13 6.83199e-17
C1486 PULLDOWN_P PULLUP_P_BLEED_5 9.89305e-19
C1487 FS_N_BLEED_3 HS_P 8.85647e-17
C1488 HS_N_2 FS_LOW_P 2.12547e-16
C1489 PULLUP_P_OUT FS_P_BLEED_0 1.46146e-16
C1490 FS_P_WELL FS_LOW_P 2.24752e-15
C1491 PULLDOWN_P PULLUP_P_GATE 3.88276e-17
C1492 PULLUP_P_WELL FS_P_BLEED_6 3.05394e-17
C1493 VDD PULLUP_P 2.44148e-15
C1494 PULLUP_P_WELL PULLDOWN_P_R 5.4541e-16
C1495 VDD FS_P_CONTROL_S 3.86206e-16
C1496 TERM_ENABLE HS_P_9 7.43459e-17
C1497 DIV_ENABLE HS_P 3.81812e-17
C1498 TERM_P_R HS_N_6 5.89263e-17
C1499 HS_N HS_N_4 1.43714e-15
C1500 HS_P_2 HS_P_1 5.6796e-17
C1501 VDD PULLDOWN_N_R 3.41738e-15
C1502 PULLUP_N_BLEED_3 HS_P 1.17851e-16
C1503 HS_N_9 FS_P_GATE 1.0428e-15
C1504 HS_N_0 HS_P_0 4.06066e-17
C1505 TERM_OR_P_B HS_P_13 1.03886e-16
C1506 HS_N_9 HS_P_5 6.57781e-17
C1507 HS_N_11 HS_P_12 6.9135e-17
C1508 HS_N_5 FS_P_OUT 4.33306e-16
C1509 HS_N_3 FS_P_CONTROL_S 3.22599e-17
C1510 HS_N_13 FS_P_BLEED_0 6.1779e-17
C1511 PULLDOWN_N_R DIV_P 1.29874e-17
C1512 HS_N_0 TERM_N_R 1.21272e-16
C1513 FS_P_BLEED_3 PULLUP_P_GATE 4.70063e-19
C1514 PULLDOWN_N_R HS_N_3 2.40376e-17
C1515 TERM_N_R TERM_OR_P_S 5.45955e-17
C1516 HS_N_4 FS_LOW_P 8.50523e-17
C1517 TERM_P_R FS_N_OUT 3.45179e-16
C1518 PULLDOWN_P PULLDOWN_P_R 5.93443e-16
C1519 DIV_LOW_N TERM_ENABLE 4.51263e-17
C1520 PULLUP_P_WELL PULLUP_P_CONTROL_S 3.85921e-16
C1521 TERM_OR_N_S TERM_OR_N_B 5.00768e-15
C1522 VDD FS_P_BLEED_0 2.50257e-16
C1523 FS_N_BLEED_0 FS_N_BLEED_2 1.17766e-16
C1524 HS_N_9 HS_P_8 1.04313e-16
C1525 HS_N_1 HS_P 1.78922e-16
C1526 HS_PBIAS HS_P_2 3.95109e-15
C1527 TERM_ENABLE HS_P_11 7.92264e-17
C1528 TERM_P_R HS_N_8 1.00539e-16
C1529 FS_N_OUT RX_P 1.28425e-17
C1530 HS_N HS_N_6 7.99416e-15
C1531 VDD PULLUP_N_GATE 1.22975e-14
C1532 PULLUP_N_OUT FS_P_BLEED_5 7.24459e-19
C1533 TERM_P_R DIV_N 4.31015e-19
C1534 TERM_OR_P_B HS_P_1 8.19117e-17
C1535 PAD_N PULLDOWN_P_R 8.44049e-17
C1536 HS_N_11 FS_P_GATE 1.01933e-15
C1537 BYPASS_ENABLE DIV_LOW_N 1.05682e-18
C1538 HS_N_11 HS_P_5 3.48887e-17
C1539 HS_N_5 FS_P_CONTROL_S 3.22599e-17
C1540 HS_N_3 FS_P_BLEED_0 6.1779e-17
C1541 HS_N_13 HS_P_12 3.62145e-17
C1542 HS_N_9 HS_P_7 4.01009e-17
C1543 HS_N_7 FS_P_OUT 5.24765e-16
C1544 HS_N_5 PULLUP_P 6.95504e-19
C1545 FS_P_BLEED_3 FS_P_BLEED_6 6.06886e-17
C1546 DIV_N RX_P 7.26653e-16
C1547 PULLUP_P_OUT FS_P_GATE 1.62552e-15
C1548 TERM_GATE_N_BLEED_1 TERM_N_R 2.01079e-16
C1549 PULLDOWN_N_R HS_N_5 6.1589e-17
C1550 HS_PBIAS TERM_GATE_N 1.74562e-16
C1551 HS_N FS_N_OUT 1.24111e-15
C1552 HS_N_6 FS_LOW_P 8.54176e-17
C1553 PULLUP_N_BLEED_0 PULLUP_N_BLEED_2 3.06736e-19
C1554 PAD_N HS_P_6 3.12636e-16
C1555 VDD HS_P_12 4.78775e-15
C1556 PAD_P PULLDOWN_P_R 2.92129e-15
C1557 FS_N_BLEED_1 FS_N_BLEED_5 1.05416e-16
C1558 PULLUP_P_WELL PULLUP_P_BLEED_0 2.68055e-15
C1559 FS_N_GATE FS_N_BLEED_2 1.79465e-16
C1560 HS_N HS_N_8 2.60585e-15
C1561 VDD PULLUP_N_BLEED_6 1.56976e-17
C1562 PULLUP_N_BLEED_2 HS_P 7.92848e-17
C1563 HS_N_13 FS_P_GATE 1.01205e-15
C1564 HS_N DIV_N 4.97739e-17
C1565 PULLDOWN_P TERM_OR_N_B 8.71322e-17
C1566 DIV_P HS_P_12 3.38809e-17
C1567 PULLUP_P_OUT HS_P_8 1.35418e-18
C1568 FS_N_GATE PULLUP_N_OUT 1.11467e-15
C1569 PULLUP_N_BLEED_1 TERM_ENABLE 6.15064e-17
C1570 FS_N_BLEED_6 FS_LOW_N 7.13436e-17
C1571 FS_N_OUT FS_LOW_P 4.64263e-16
C1572 HS_P_3 HS_P_10 2.86636e-17
C1573 HS_N_13 HS_P_5 3.48887e-17
C1574 HS_N_3 HS_P_12 3.48887e-17
C1575 HS_N_7 FS_P_CONTROL_S 3.22599e-17
C1576 HS_N_5 FS_P_BLEED_0 6.1779e-17
C1577 TERM_VCM PULLUP_P_BLEED_4 3.47206e-17
C1578 HS_N_7 PULLUP_P 5.06175e-17
C1579 HS_N_9 HS_P_9 6.70368e-17
C1580 FS_P_BLEED_2 FS_HIGH_P 1.66126e-16
C1581 DIV_ENABLE FS_P_OUT 6.28968e-17
C1582 PAD_P HS_P_6 1.8306e-15
C1583 TERM_P_R VCM_LOW_OK 3.48282e-16
C1584 TERM_GATE_N_BLEED_2 TERM_N_R 1.15649e-16
C1585 HS_N_10 TERM_GATE_N 4.86854e-17
C1586 VDD FS_P_GATE 2.88959e-14
C1587 PULLDOWN_N_R HS_N_7 6.83199e-17
C1588 PULLUP_N_BLEED_1 BYPASS_ENABLE 7.65665e-18
C1589 HS_N_8 FS_LOW_P 8.56122e-17
C1590 DIV_N FS_LOW_P 6.00722e-15
C1591 PULLUP_N PULLUP_N_BLEED_3 1.89753e-16
C1592 VDD HS_P_5 4.75167e-15
C1593 PULLUP_P_BLEED_1 PULLUP_P_BLEED_4 7.80014e-18
C1594 HS_N_10 TERM_OR_P_B 7.38007e-17
C1595 TERM_ENABLE HS_P_0 3.03728e-17
C1596 FS_N_OUT RX_N 1.56572e-17
C1597 HS_N_3 FS_P_GATE 1.011e-15
C1598 PULLUP_P FS_N_BLEED_3 4.81895e-17
C1599 FS_N_BLEED_6 FS_N_BLEED_4 8.54567e-18
C1600 HS_N_9 DIV_LOW_N 6.1779e-17
C1601 TERM_N_R TERM_ENABLE 5.47295e-16
C1602 VDD HS_P_8 4.99906e-15
C1603 FS_P_BLEED_5 PULLUP_P_WELL 6.74983e-19
C1604 HS_N_3 HS_P_5 3.48887e-17
C1605 HS_N_9 HS_P_11 3.10308e-17
C1606 HS_N_5 HS_P_12 6.57781e-17
C1607 HS_N_7 FS_P_BLEED_0 6.1779e-17
C1608 TERM_N_R FS_N_BLEED_5 1.14443e-16
C1609 HS_N_1 FS_P_OUT 4.46857e-16
C1610 PULLDOWN_N_R FS_N_BLEED_3 9.11073e-17
C1611 HS_N VCM_LOW_OK 4.12239e-17
C1612 DIV_ENABLE PULLUP_P 5.06175e-17
C1613 DIV_N RX_N 1.36638e-15
C1614 PULLUP_P PULLUP_N_BLEED_3 1.52593e-19
C1615 TERM_N_R BYPASS_ENABLE 4.44394e-18
C1616 PULLDOWN_N_R DIV_ENABLE 4.45496e-17
C1617 HS_N_12 TERM_GATE_N 4.84401e-17
C1618 PULLUP_P_OUT HS_P_9 6.89716e-17
C1619 HS_P_13 HS_P_1 1.13522e-16
C1620 FS_N_BLEED_2 HS_P 9.01557e-17
C1621 FS_N_BLEED_6 VDD 4.51172e-16
C1622 PULLDOWN_N_R PULLUP_N_BLEED_3 7.92848e-17
C1623 VDD HS_P_7 4.96081e-15
C1624 HS_PBIAS FS_P_BLEED_4 8.38415e-17
C1625 TERM_ENABLE HS_P_4 7.92264e-17
C1626 HS_N_2 HS_P_2 6.70368e-17
C1627 PULLUP_N_BLEED_1 DIFF_ENABLE 1.12958e-18
C1628 HS_N_12 TERM_OR_P_B 7.3066e-17
C1629 PULLUP_N_OUT HS_P 9.36445e-17
C1630 PULLUP_P_BLEED_3 PULLUP_P_BLEED_4 3.81017e-15
C1631 FS_LOW_N DIV_LOW_N 6.1779e-17
C1632 VCM_LOW_OK FS_LOW_P 2.2718e-16
C1633 HS_N_5 FS_P_GATE 1.02138e-15
C1634 HS_N_11 DIV_LOW_N 6.1779e-17
C1635 HS_P_3 TERM_OR_P_NS 2.84614e-17
C1636 HS_N_7 HS_P_12 3.48887e-17
C1637 HS_N_1 FS_P_CONTROL_S 3.24013e-17
C1638 HS_N_1 PULLUP_P 5.06175e-17
C1639 HS_N_11 HS_P_11 6.80583e-17
C1640 HS_N_5 HS_P_5 1.02947e-16
C1641 DIV_LOW_P TERM_GATE_P 4.27971e-18
C1642 HS_N PULLUP_P_BLEED_6 5.04752e-17
C1643 TERM_P_R PULLUP_P_GATE 2.08715e-16
C1644 HS_N_2 TERM_GATE_N 5.05962e-17
C1645 TERM_VCM PULLUP_P_BLEED_2 1.88161e-17
C1646 HS_PBIAS HS_P_13 2.35174e-15
C1647 PULLDOWN_N_R HS_N_1 6.83199e-17
C1648 TERM_N_R FS_N_CONTROL_S 5.8592e-17
C1649 PULLUP_N_GATE DIV_ENABLE 6.06007e-19
C1650 PULLUP_P_OUT HS_P_11 5.51888e-17
C1651 TERM_VCM HS_P_3 1.20188e-16
C1652 PULLUP_N PULLUP_N_BLEED_2 2.26497e-16
C1653 PULLUP_N_WELL FS_HIGH_P 2.13545e-16
C1654 VDD HS_P_9 6.02581e-15
C1655 PULLUP_N_GATE PULLUP_N_BLEED_3 8.1379e-17
C1656 PULLUP_P_BLEED_1 PULLUP_P_BLEED_2 7.61291e-16
C1657 HS_N_10 FS_P_BLEED_4 2.91546e-17
C1658 HS_N_0 PULLUP_P_BLEED_4 3.48887e-17
C1659 FS_N_BLEED_1 FS_LOW_N 1.05682e-18
C1660 HS_N_4 HS_P_2 3.76364e-18
C1661 HS_N_2 TERM_OR_P_B 7.25839e-17
C1662 TERM_N_R DIFF_ENABLE 4.32386e-15
C1663 TERM_ENABLE TERM_GATE_P_BLEED_0 9.80321e-17
C1664 FS_P_BLEED_5 FS_P_BLEED_3 1.28312e-16
C1665 HS_N_7 FS_P_GATE 1.02868e-15
C1666 HS_N_13 DIV_LOW_N 6.1779e-17
C1667 FS_HIGH_N HS_PBIAS 3.74305e-17
C1668 TERM_VCM FS_HIGH_P 1.35668e-16
C1669 HS_N PULLUP_P_BLEED_5 1.02101e-16
C1670 HS_PBIAS HS_P_1 2.59892e-15
C1671 HS_N_7 HS_P_5 3.48887e-17
C1672 HS_N_1 FS_P_BLEED_0 6.1779e-17
C1673 HS_N_9 HS_P_0 3.79083e-17
C1674 PULLDOWN_N_R TERM_GATE_P_BLEED_1 1.94556e-18
C1675 TERM_P_R PULLDOWN_P_R 1.63221e-16
C1676 FS_N_GATE PULLDOWN_P 1.32493e-15
C1677 HS_N PULLUP_P_GATE 1.66091e-16
C1678 TERM_VCM FS_P_BLEED_2 3.47206e-17
C1679 FS_LOW_N PULLUP_N_BLEED_1 7.12642e-17
C1680 HS_N_4 TERM_GATE_N 4.80752e-17
C1681 VDD DIV_LOW_N 1.17561e-18
C1682 HS_P_10 TERM_OR_P_NS 4.32898e-17
C1683 TERM_N_R HS_N_9 5.94779e-17
C1684 HS_N_10 HS_P_13 2.51995e-17
C1685 PULLDOWN_N_R PULLUP_N_BLEED_2 7.92848e-17
C1686 FS_N_BLEED_1 FS_N_BLEED_4 1.22362e-16
C1687 VDD HS_P_11 5.06957e-15
C1688 HS_N_12 FS_P_BLEED_4 2.88761e-17
C1689 HS_N_6 HS_P_2 3.08895e-17
C1690 HS_N_4 TERM_OR_P_B 7.21128e-17
C1691 TERM_OR_N_S HS_P 9.56294e-17
C1692 PULLUP_P_BLEED_5 FS_LOW_P 7.81006e-17
C1693 TERM_VCM HS_P_10 1.34912e-16
C1694 TERM_P_R HS_P_6 8.35623e-17
C1695 FS_HIGH_N FS_N_WELL 6.32864e-16
C1696 PULLUP_P_BLEED_3 PULLUP_P_BLEED_2 2.29663e-15
C1697 PULLUP_P_GATE FS_LOW_P 6.87755e-17
C1698 DIV_ENABLE FS_P_GATE 4.24205e-18
C1699 HS_N_3 DIV_LOW_N 6.1779e-17
C1700 HS_PBIAS PULLUP_N_CONTROL_S 9.33173e-17
C1701 HS_P PULLUP_P_WELL 2.91847e-16
C1702 HS_N_7 HS_P_7 2.55858e-19
C1703 HS_N_9 HS_P_4 3.08895e-17
C1704 HS_N_1 HS_P_12 6.33501e-17
C1705 HS_N FS_P_BLEED_6 8.04284e-17
C1706 HS_N_11 HS_P_0 4.3885e-17
C1707 DIV_ENABLE HS_P_5 2.52105e-18
C1708 TERM_P_R PULLUP_P_CONTROL_S 4.71855e-17
C1709 PULLUP_N_OUT FS_P_OUT 5.83221e-16
C1710 FS_LOW_N TERM_N_R 1.91325e-16
C1711 HS_N PULLDOWN_P_R 4.38785e-17
C1712 HS_N_12 HS_P_13 2.46514e-17
C1713 HS_N_6 TERM_GATE_N 5.14347e-17
C1714 TERM_N_R HS_N_11 5.99647e-17
C1715 PULLUP_N_OUT PULLUP_N 1.04554e-18
C1716 TERM_P_R TERM_OR_N_B 3.6281e-16
C1717 PULLUP_N_BLEED_5 PULLUP_N_BLEED_3 6.56802e-17
C1718 PULLUP_N_GATE PULLUP_N_BLEED_2 6.88689e-17
C1719 HS_N_2 FS_P_BLEED_4 2.84614e-17
C1720 TERM_P_R TERM_GATE_P 2.6175e-14
C1721 HS_N_8 HS_P_2 2.40376e-17
C1722 HS_N_6 TERM_OR_P_B 7.21128e-17
C1723 TERM_N_R PULLUP_P_OUT 1.42869e-16
C1724 PULLUP_N_BLEED_0 PULLDOWN_P 1.05682e-18
C1725 VDD PULLUP_N_BLEED_1 4.56068e-16
C1726 PULLDOWN_P_R FS_LOW_P 6.53881e-17
C1727 HS_N HS_P_6 5.26502e-16
C1728 FS_N_BLEED_6 FS_N_BLEED_3 7.80014e-18
C1729 HS_PBIAS FS_N_WELL 3.62026e-15
C1730 HS_N_1 FS_P_GATE 1.02597e-15
C1731 FS_N_OUT TERM_GATE_N 5.08233e-17
C1732 HS_N_5 DIV_LOW_N 6.1779e-17
C1733 HS_PBIAS HS_N_10 1.07528e-15
C1734 HS_N_0 HS_P_3 2.68576e-17
C1735 HS_N_5 HS_P_11 3.08895e-17
C1736 HS_N_1 HS_P_5 3.48887e-17
C1737 TERM_N_R FS_N_BLEED_4 5.72918e-17
C1738 FS_N_BLEED_6 DIV_ENABLE 3.56355e-17
C1739 PULLDOWN_N_R FS_N_BLEED_2 5.18804e-17
C1740 HS_N_9 TERM_GATE_P_BLEED_0 1.05304e-18
C1741 HS_N PULLUP_P_CONTROL_S 4.82815e-17
C1742 PULLUP_N_OUT PULLUP_P 2.95964e-14
C1743 FS_N_OUT TERM_OR_P_B 5.08233e-17
C1744 TERM_N_R HS_N_13 5.95247e-17
C1745 HS_N_2 HS_P_13 7.76185e-17
C1746 FS_P_WELL HS_P_13 2.21209e-16
C1747 HS_N_8 TERM_GATE_N 5.3859e-17
C1748 PULLUP_P_OUT HS_P_4 5.51888e-17
C1749 PULLDOWN_N PULLUP_N 5.39744e-17
C1750 PULLUP_N_OUT PULLDOWN_N_R 1.20532e-16
C1751 PAD_N HS_P 1.82419e-15
C1752 DIV_N TERM_GATE_N 1.70326e-17
C1753 TERM_ENABLE PULLUP_P_BLEED_4 6.02823e-17
C1754 HS_P_6 FS_LOW_P 4.566e-17
C1755 HS_N_4 FS_P_BLEED_4 3.2583e-17
C1756 HS_N TERM_OR_N_B 8.49624e-17
C1757 VDD HS_P_0 3.95338e-15
C1758 PULLUP_N_BLEED_4 PULLUP_N_BLEED_3 2.05029e-15
C1759 HS_N_0 FS_HIGH_P 3.42328e-19
C1760 PULLUP_N_WELL TERM_VCM 3.05846e-16
C1761 HS_N TERM_GATE_P 1.75618e-16
C1762 HS_N_8 TERM_OR_P_B 7.24454e-17
C1763 TERM_VCM TERM_OR_P_NS 1.29841e-18
C1764 HS_N_0 FS_P_BLEED_2 3.47206e-17
C1765 BYPASS_ENABLE PULLUP_P_BLEED_4 7.65665e-18
C1766 VDD TERM_N_R 6.61679e-15
C1767 TERM_OR_P_B DIV_N 1.34827e-18
C1768 PULLUP_P_CONTROL_S FS_LOW_P 8.47923e-17
C1769 HS_N_10 FS_N_WELL 1.99681e-17
C1770 HS_N_7 DIV_LOW_N 6.1779e-17
C1771 HS_PBIAS HS_N_12 2.63945e-15
C1772 HS_N_2 HS_P_1 9.79781e-17
C1773 HS_P PAD_P 3.98004e-14
C1774 HS_P_2 VCM_LOW_OK 3.48887e-17
C1775 HS_N_7 HS_P_11 1.52593e-19
C1776 PULLUP_N_OUT FS_P_BLEED_0 1.1535e-16
C1777 PULLDOWN_N PULLUP_P 6.10321e-17
C1778 HS_N_4 HS_P_13 2.95679e-17
C1779 TERM_GATE_P FS_LOW_P 1.53568e-16
C1780 TERM_N_R HS_N_3 5.89263e-17
C1781 PULLUP_P_OUT TERM_GATE_P_BLEED_0 1.01098e-16
C1782 PULLDOWN_N PULLDOWN_N_R 5.82803e-15
C1783 PULLUP_N_OUT PULLUP_N_GATE 1.81444e-14
C1784 VDD HS_P_4 4.77123e-15
C1785 PULLUP_N_BLEED_5 PULLUP_N_BLEED_2 2.51934e-18
C1786 TERM_GATE_N_BLEED_1 FS_HIGH_P 1.58071e-16
C1787 HS_N_6 FS_P_BLEED_4 3.58482e-17
C1788 TERM_GATE_N VCM_LOW_OK 5.30337e-18
C1789 HS_N_12 FS_N_WELL 2.01404e-17
C1790 HS_N_10 HS_N_12 1.1003e-17
C1791 DIV_ENABLE DIV_LOW_N 8.13107e-15
C1792 HS_PBIAS HS_N_2 2.89631e-15
C1793 FS_P_WELL HS_PBIAS 3.64298e-15
C1794 HS_N_4 HS_P_1 5.86016e-17
C1795 HS_N_5 HS_P_0 3.73287e-17
C1796 TERM_OR_P_B VCM_LOW_OK 2.10826e-15
C1797 HS_PBIAS FS_P_BLEED_1 8.85647e-17
C1798 FS_N_OUT FS_P_BLEED_4 6.63891e-17
C1799 TERM_OR_N_S PULLUP_P 1.46572e-16
C1800 PULLUP_N_OUT HS_P_12 3.00582e-17
C1801 HS_N_6 HS_P_13 5.49271e-17
C1802 PULLDOWN_N_R TERM_OR_N_S 1.27566e-16
C1803 TERM_N_R HS_N_5 5.89263e-17
C1804 PULLDOWN_N PULLUP_N_GATE 1.32582e-18
C1805 TERM_ENABLE PULLUP_P_BLEED_2 8.22106e-17
C1806 PULLUP_P PULLUP_P_WELL 4.11378e-16
C1807 FS_N_BLEED_1 FS_N_BLEED_3 1.20364e-16
C1808 PULLUP_N_BLEED_4 PULLUP_N_BLEED_2 3.26487e-18
C1809 TERM_GATE_N_BLEED_2 FS_HIGH_P 1.34735e-17
C1810 HS_N_8 FS_P_BLEED_4 4.2854e-17
C1811 VDD TERM_GATE_P_BLEED_0 1.21311e-16
C1812 HS_N FS_P_BLEED_5 8.04284e-17
C1813 PULLUP_N PULLDOWN_P 5.71742e-15
C1814 TERM_VCM PULLUP_P_BLEED_3 9.09595e-17
C1815 HS_P_3 TERM_ENABLE 7.67984e-17
C1816 HS_N_9 PULLUP_P_BLEED_4 3.48887e-17
C1817 PULLDOWN_N_R PULLUP_P_WELL 4.14822e-16
C1818 PAD_N FS_P_OUT 1.89403e-15
C1819 HS_N_10 HS_N_2 4.41474e-17
C1820 HS_N_1 DIV_LOW_N 6.92554e-17
C1821 HS_PBIAS HS_N_4 1.07268e-15
C1822 FS_N_BLEED_0 HS_N 2.11753e-17
C1823 FS_N_GATE TERM_P_R 8.04253e-16
C1824 PULLUP_N_OUT FS_P_GATE 1.26827e-15
C1825 FS_P_WELL HS_N_10 2.04554e-15
C1826 HS_N_6 HS_P_1 3.09936e-17
C1827 PULLUP_P_BLEED_3 PULLUP_P_BLEED_1 1.09742e-16
C1828 HS_N_1 HS_P_11 2.84614e-17
C1829 HS_N_7 HS_P_0 4.04393e-19
C1830 HS_N_10 FS_P_BLEED_1 6.1779e-17
C1831 HS_N_5 HS_P_4 1.33069e-16
C1832 PULLUP_N_OUT HS_P_5 2.85937e-17
C1833 FS_P_BLEED_3 FS_P_OUT 3.14506e-19
C1834 TERM_ENABLE FS_HIGH_P 2.05054e-17
C1835 TERM_OR_N_NS VCM_LOW_OK 2.03284e-15
C1836 HS_N_8 HS_P_13 4.82763e-17
C1837 TERM_OR_P_S TERM_OR_P_NS 7.35739e-18
C1838 TERM_N_R HS_N_7 1.09296e-16
C1839 FS_N_BLEED_5 FS_HIGH_P 1.52593e-19
C1840 PULLUP_N_BLEED_1 DIV_ENABLE 3.56355e-17
C1841 PULLDOWN_N PULLUP_N_BLEED_6 8.324e-18
C1842 TERM_ENABLE FS_P_BLEED_2 5.902e-17
C1843 PAD_P FS_P_OUT 5.93556e-15
C1844 PULLUP_N_BLEED_1 PULLUP_N_BLEED_3 1.53064e-18
C1845 PULLUP_P_WELL FS_P_BLEED_0 6.74983e-19
C1846 FS_HIGH_N FS_N_OUT 2.03025e-17
C1847 FS_N_BLEED_0 FS_LOW_P 8.35148e-16
C1848 BYPASS_ENABLE FS_HIGH_P 7.62967e-20
C1849 PULLUP_N_OUT HS_P_8 4.29014e-17
C1850 TERM_VCM HS_N_0 1.84191e-16
C1851 FS_LOW_N PULLUP_P_BLEED_4 2.19908e-17
C1852 PULLDOWN_N_R PULLDOWN_P 8.74701e-14
C1853 HS_N_11 PULLUP_P_BLEED_4 3.48887e-17
C1854 TERM_VCM TERM_OR_P_S 5.9623e-17
C1855 FS_N_BLEED_6 FS_N_BLEED_2 7.62796e-18
C1856 BYPASS_ENABLE FS_P_BLEED_2 7.65665e-18
C1857 FS_N_GATE HS_N 2.05519e-15
C1858 TERM_ENABLE HS_P_10 7.67984e-17
C1859 HS_N_12 HS_N_2 3.55427e-17
C1860 HS_N_10 HS_N_4 2.82661e-19
C1861 FS_P_WELL HS_N_12 1.97719e-15
C1862 HS_PBIAS HS_N_6 4.87661e-15
C1863 HS_N_8 HS_P_1 2.86636e-17
C1864 HS_P_2 PULLDOWN_P_R 7.46551e-17
C1865 PAD_N PULLDOWN_N_R 4.48191e-15
C1866 HS_N_5 TERM_GATE_P_BLEED_0 3.33636e-19
C1867 PULLUP_N_OUT HS_P_7 2.84614e-17
C1868 HS_N_12 FS_P_BLEED_1 6.1779e-17
C1869 FS_N_BLEED_6 PULLUP_N_OUT 5.44487e-17
C1870 TERM_N_R DIV_ENABLE 1.69354e-16
C1871 PULLDOWN_N PULLUP_N_BLEED_5 7.80014e-18
C1872 TERM_P_R PULLUP_N_BLEED_0 1.11498e-16
C1873 TERM_VCM TERM_GATE_N_BLEED_1 4.28264e-17
C1874 FS_N_GATE FS_LOW_P 4.04336e-16
C1875 HS_PBIAS FS_N_OUT 9.49388e-16
C1876 HS_P_13 VCM_LOW_OK 3.48887e-17
C1877 DIV_LOW_P FS_P_OUT 1.36053e-16
C1878 PULLUP_N_GATE PULLDOWN_P 2.06889e-16
C1879 HS_N_13 PULLUP_P_BLEED_4 3.48887e-17
C1880 TERM_P_R HS_P 1.66901e-16
C1881 PULLDOWN_N_R PAD_P 1.40429e-15
C1882 HS_P_2 HS_P_6 6.95596e-17
C1883 HS_N_12 HS_N_4 6.21526e-19
C1884 HS_N_10 HS_N_6 1.52593e-19
C1885 FS_HIGH_P DIFF_ENABLE 1.99196e-16
C1886 HS_PBIAS HS_N_8 9.64282e-15
C1887 FS_P_WELL HS_N_2 1.92332e-15
C1888 HS_PBIAS DIV_N 1.39005e-16
C1889 HS_N_1 HS_P_0 4.11318e-17
C1890 HS_P_3 HS_N_9 3.08895e-17
C1891 TERM_OR_P_B PULLDOWN_P_R 1.79486e-16
C1892 PULLUP_N_OUT HS_P_9 7.92848e-17
C1893 HS_N_2 FS_P_BLEED_1 6.1779e-17
C1894 VDD PULLUP_P_BLEED_4 4.46636e-16
C1895 TERM_N_R TERM_GATE_N_BLEED_0 1.69431e-16
C1896 HS_N_7 TERM_GATE_P_BLEED_0 5.67482e-19
C1897 PULLUP_P_WELL FS_P_GATE 5.65411e-18
C1898 FS_P_WELL FS_P_BLEED_1 1.19387e-16
C1899 TERM_N_R HS_N_1 1.25932e-16
C1900 HS_P_1 VCM_LOW_OK 3.48887e-17
C1901 PULLDOWN_N PULLUP_N_BLEED_4 7.62796e-18
C1902 FS_N_OUT FS_N_WELL 2.26561e-13
C1903 PULLUP_N_BLEED_1 PULLUP_N_BLEED_2 5.20556e-15
C1904 HS_N_10 FS_N_OUT 5.27536e-18
C1905 HS_P_2 TERM_GATE_P 1.57176e-16
C1906 HS_N_9 FS_HIGH_P 1.12441e-17
C1907 TERM_VCM TERM_GATE_N_BLEED_2 1.50283e-17
C1908 HS_N_3 PULLUP_P_BLEED_4 3.48887e-17
C1909 HS_N HS_P 2.27647e-15
C1910 TERM_OR_P_B HS_P_6 1.01328e-16
C1911 PULLUP_N_WELL TERM_ENABLE 5.48445e-16
C1912 HS_N_9 FS_P_BLEED_2 3.47206e-17
C1913 PAD_N HS_P_12 2.23241e-16
C1914 TERM_ENABLE TERM_OR_P_NS 1.64203e-16
C1915 HS_N_2 HS_N_4 2.0615e-18
C1916 HS_N_12 HS_N_6 2.82661e-19
C1917 FS_P_WELL HS_N_4 1.94169e-15
C1918 PULLUP_N_WELL FS_N_BLEED_5 6.74983e-19
C1919 PULLUP_N_OUT DIV_LOW_N 4.91138e-17
C1920 FS_P_BLEED_4 PULLUP_P_GATE 4.70063e-19
C1921 HS_N_10 DIV_N 3.31088e-17
C1922 TERM_N_R TERM_GATE_P_BLEED_1 2.37672e-16
C1923 TERM_GATE_N TERM_OR_N_B 2.35341e-15
C1924 HS_N_4 FS_P_BLEED_1 6.1779e-17
C1925 HS_P_3 HS_N_11 2.5076e-17
C1926 PULLUP_N_OUT HS_P_11 8.82385e-17
C1927 PULLUP_N_WELL BYPASS_ENABLE 8.22717e-18
C1928 TERM_VCM TERM_ENABLE 5.22073e-16
C1929 HS_PBIAS VCM_LOW_OK 4.04793e-16
C1930 HS_N_9 HS_P_10 3.10917e-17
C1931 HS_P FS_LOW_P 9.86342e-17
C1932 HS_P_3 PULLUP_P_OUT 5.27608e-17
C1933 FS_LOW_N FS_HIGH_P 9.38697e-14
C1934 TERM_VCM FS_N_BLEED_5 1.37591e-16
C1935 PAD_P HS_P_12 1.66835e-15
C1936 FS_N_BLEED_1 FS_N_BLEED_2 3.07801e-15
C1937 TERM_OR_P_B TERM_GATE_P 1.29405e-14
C1938 HS_N_12 FS_N_OUT 5.27536e-18
C1939 HS_N_11 FS_HIGH_P 3.07681e-19
C1940 PULLUP_N_BLEED_5 PULLDOWN_P 3.19536e-18
C1941 TERM_ENABLE PULLUP_P_BLEED_1 6.06002e-18
C1942 HS_N_5 PULLUP_P_BLEED_4 3.48887e-17
C1943 TERM_VCM BYPASS_ENABLE 8.88787e-18
C1944 PAD_N HS_P_5 1.55482e-15
C1945 HS_N_11 FS_P_BLEED_2 3.47206e-17
C1946 HS_N_2 HS_N_6 6.21526e-19
C1947 HS_N_12 HS_N_8 1.52593e-19
C1948 FS_P_BLEED_4 FS_P_BLEED_6 1.20364e-16
C1949 FS_P_BLEED_3 FS_P_GATE 1.16665e-16
C1950 HS_N_12 DIV_N 3.31088e-17
C1951 FS_P_WELL HS_N_6 1.94094e-15
C1952 HS_N_6 FS_P_BLEED_1 6.1779e-17
C1953 HS_N_0 TERM_GATE_N_BLEED_1 3.48887e-17
C1954 HS_P_3 HS_N_13 2.4636e-17
C1955 TERM_N_R TERM_GATE_P_BLEED_2 8.43202e-16
C1956 TERM_P_R FS_P_OUT 4.32308e-16
C1957 FS_P_BLEED_2 PULLUP_P_OUT 5.902e-17
C1958 PAD_N HS_P_8 8.55121e-16
C1959 VDD PULLUP_P_BLEED_2 1.76048e-17
C1960 HS_N_10 VCM_LOW_OK 3.48887e-17
C1961 FS_N_BLEED_4 FS_HIGH_P 2.0817e-19
C1962 HS_N_11 HS_P_10 1.40305e-16
C1963 HS_PBIAS PULLUP_P_BLEED_6 1.74058e-16
C1964 FS_N_BLEED_6 PULLDOWN_P 4.81135e-17
C1965 PULLUP_N_OUT PULLUP_N_BLEED_1 3.04895e-18
C1966 TERM_P_R PULLUP_N 1.81265e-16
C1967 RX_P FS_P_OUT 1.23787e-17
C1968 PAD_P HS_P_5 1.15443e-15
C1969 HS_N_2 FS_N_OUT 6.16744e-17
C1970 TERM_OR_N_NS TERM_OR_N_B 9.45768e-16
C1971 VDD HS_P_3 6.14484e-15
C1972 PULLUP_P_OUT HS_P_10 5.27608e-17
C1973 FS_P_WELL FS_N_OUT 9.51456e-16
C1974 PULLUP_N_BLEED_4 PULLDOWN_P 8.01443e-17
C1975 HS_P_13 PULLDOWN_P_R 2.40376e-17
C1976 HS_N_7 PULLUP_P_BLEED_4 3.48887e-17
C1977 TERM_VCM FS_N_CONTROL_S 4.23029e-17
C1978 FS_N_OUT FS_P_BLEED_1 1.44632e-16
C1979 PAD_N HS_P_7 3.61296e-16
C1980 HS_N_13 FS_P_BLEED_2 3.47206e-17
C1981 TERM_GATE_P_BLEED_0 TERM_GATE_P_BLEED_1 2.63577e-15
C1982 PULLUP_P_BLEED_3 TERM_ENABLE 1.12285e-16
C1983 HS_N_2 HS_N_8 2.82661e-19
C1984 PAD_P HS_P_8 1.09993e-15
C1985 FS_P_WELL HS_N_8 1.96551e-15
C1986 HS_N_4 HS_N_6 7.07539e-17
C1987 HS_N_2 DIV_N 3.31088e-17
C1988 FS_P_WELL DIV_N 9.96855e-16
C1989 VDD FS_HIGH_P 8.36822e-16
C1990 HS_N_0 TERM_GATE_N_BLEED_2 5.29295e-17
C1991 HS_N_8 FS_P_BLEED_1 6.1779e-17
C1992 HS_P_3 HS_N_3 3.7333e-17
C1993 TERM_P_R PULLUP_P 2.69783e-16
C1994 HS_N FS_P_OUT 2.04712e-14
C1995 PULLUP_N_OUT HS_P_0 9.23731e-17
C1996 HS_PBIAS PULLUP_P_BLEED_5 7.92848e-17
C1997 HS_N_9 TERM_OR_P_NS 1.00158e-17
C1998 VDD FS_P_BLEED_2 4.46753e-16
C1999 HS_N_12 VCM_LOW_OK 3.48887e-17
C2000 HS_N_10 PULLUP_P_BLEED_6 2.44119e-17
C2001 HS_PBIAS PULLUP_P_GATE 1.62174e-16
C2002 HS_P_13 HS_P_6 1.59595e-16
C2003 TERM_P_R PULLDOWN_N_R 1.78924e-16
C2004 PULLUP_N_OUT TERM_N_R 2.96166e-16
C2005 HS_P_1 PULLDOWN_P_R 8.5948e-17
C2006 PAD_P HS_P_7 1.52213e-15
C2007 DIV_LOW_P HS_P_5 3.04895e-18
C2008 TERM_VCM HS_N_9 1.48755e-16
C2009 VDD HS_P_10 6.63169e-15
C2010 DIV_ENABLE PULLUP_P_BLEED_4 1.37454e-17
C2011 PAD_N HS_P_9 6.47937e-15
C2012 FS_P_OUT FS_LOW_P 5.67106e-16
C2013 HS_N_0 TERM_ENABLE 1.03356e-16
C2014 HS_N_3 FS_P_BLEED_2 3.47206e-17
C2015 TERM_OR_P_S TERM_ENABLE 2.30412e-16
C2016 TERM_GATE_P_BLEED_0 TERM_GATE_P_BLEED_2 1.07587e-16
C2017 HS_N_4 HS_N_8 4.06164e-17
C2018 HS_N_4 DIV_N 3.31088e-17
C2019 HS_P_3 HS_N_5 3.08895e-17
C2020 HS_P_6 HS_P_1 6.27077e-17
C2021 HS_N FS_P_CONTROL_S 4.34218e-17
C2022 PULLUP_N_WELL FS_LOW_N 1.37553e-16
C2023 PULLUP_N_OUT HS_P_4 8.62998e-17
C2024 TERM_GATE_N_BLEED_1 TERM_GATE_N_BLEED_2 7.29504e-15
C2025 TERM_P_R FS_P_BLEED_0 4.59561e-17
C2026 HS_P_13 TERM_GATE_P 1.57749e-16
C2027 HS_N_10 PULLUP_P_BLEED_5 5.26957e-17
C2028 HS_PBIAS FS_P_BLEED_6 8.85647e-17
C2029 DIV_LOW_N PULLDOWN_P 8.77472e-17
C2030 HS_N_2 VCM_LOW_OK 3.48887e-17
C2031 HS_N_12 PULLUP_P_BLEED_6 2.42729e-17
C2032 HS_N_10 PULLUP_P_GATE 7.41399e-17
C2033 HS_PBIAS PULLDOWN_P_R 5.05936e-16
C2034 PULLDOWN_N TERM_N_R 2.06963e-16
C2035 FS_P_WELL VCM_LOW_OK 1.37128e-15
C2036 HS_N PULLDOWN_N_R 3.05505e-17
C2037 TERM_P_R PULLUP_N_GATE 1.79634e-16
C2038 RX_N FS_P_OUT 5.05342e-18
C2039 PAD_P HS_P_9 1.35439e-15
C2040 PULLUP_P_OUT TERM_OR_P_NS 1.01098e-16
C2041 TERM_VCM FS_LOW_N 1.28777e-16
C2042 FS_P_BLEED_1 VCM_LOW_OK 1.49741e-16
C2043 HS_N_1 PULLUP_P_BLEED_4 3.48887e-17
C2044 TERM_VCM HS_N_11 1.20188e-16
C2045 TERM_GATE_N_BLEED_1 TERM_ENABLE 4.881e-17
C2046 PAD_N HS_P_11 1.42473e-15
C2047 HS_N_5 FS_P_BLEED_2 3.47206e-17
C2048 HS_P_1 TERM_GATE_P 2.54341e-16
C2049 HS_N_6 HS_N_8 4.94565e-17
C2050 PULLUP_N_WELL FS_N_BLEED_4 6.74983e-19
C2051 HS_N_6 DIV_N 3.31088e-17
C2052 TERM_VCM PULLUP_P_OUT 3.9727e-16
C2053 HS_PBIAS HS_P_6 2.09103e-15
C2054 PULLDOWN_N_R FS_LOW_P 6.29017e-17
C2055 HS_N FS_P_BLEED_0 7.7631e-17
C2056 TERM_P_R HS_P_12 1.10662e-16
C2057 PULLUP_N_OUT TERM_GATE_P_BLEED_0 1.06795e-16
C2058 HS_N_12 PULLUP_P_BLEED_5 5.26312e-17
C2059 TERM_GATE_N_BLEED_1 BYPASS_ENABLE 7.65665e-18
C2060 HS_N_5 HS_P_10 3.08895e-17
C2061 HS_N_4 VCM_LOW_OK 3.48887e-17
C2062 HS_N_10 FS_P_BLEED_6 6.1779e-17
C2063 HS_PBIAS PULLUP_P_CONTROL_S 4.82815e-17
C2064 HS_N_2 PULLUP_P_BLEED_6 2.40376e-17
C2065 TERM_N_R TERM_OR_N_S 1.3199e-16
C2066 HS_N_10 PULLDOWN_P_R 2.43619e-17
C2067 HS_N_12 PULLUP_P_GATE 7.3256e-17
C2068 TERM_P_R PULLUP_N_BLEED_6 4.60595e-17
C2069 HS_N PULLUP_N_GATE 1.79717e-16
C2070 FS_P_BLEED_5 FS_P_BLEED_4 1.99363e-15
C2071 TERM_VCM FS_N_BLEED_4 2.04122e-17
C2072 PAD_P HS_P_11 1.25724e-15
C2073 PULLUP_N_WELL VDD 2.26537e-14
C2074 TERM_VCM HS_N_13 1.20188e-16
C2075 PULLUP_N_BLEED_1 PULLDOWN_P 4.15346e-17
C2076 HS_PBIAS TERM_OR_N_B 5.9206e-17
C2077 FS_N_OUT DIV_N 7.74836e-17
C2078 VDD TERM_OR_P_NS 4.36598e-17
C2079 HS_P_2 HS_P 7.07711e-15
C2080 TERM_N_R PULLUP_P_WELL 3.32612e-16
C2081 HS_PBIAS TERM_GATE_P 2.24085e-17
C2082 TERM_GATE_N_BLEED_2 TERM_ENABLE 7.92848e-17
C2083 HS_N_7 FS_P_BLEED_2 3.47206e-17
C2084 TERM_P_R FS_P_GATE 7.60354e-16
C2085 HS_N_8 DIV_N 3.31088e-17
C2086 HS_N_10 HS_P_6 5.97008e-17
C2087 PULLUP_N_GATE FS_LOW_P 4.93931e-17
C2088 TERM_P_R HS_P_5 8.37422e-17
C2089 HS_N HS_P_12 5.56696e-16
C2090 VDD TERM_VCM 4.03484e-14
C2091 HS_N_2 PULLUP_P_BLEED_5 5.2499e-17
C2092 HS_N_0 HS_N_9 3.91118e-17
C2093 HS_N_12 FS_P_BLEED_6 6.1779e-17
C2094 HS_N_3 TERM_OR_P_NS 1.52957e-18
C2095 HS_P TERM_GATE_N 5.93302e-17
C2096 HS_N_7 HS_P_10 2.0817e-19
C2097 HS_N_10 PULLUP_P_CONTROL_S 3.48887e-17
C2098 FS_N_BLEED_3 FS_HIGH_P 2.82661e-19
C2099 HS_N_2 PULLUP_P_GATE 7.25839e-17
C2100 HS_N_4 PULLUP_P_BLEED_6 2.90558e-17
C2101 HS_N_12 PULLDOWN_P_R 2.42376e-17
C2102 HS_N_6 VCM_LOW_OK 3.54947e-17
C2103 HS_PBIAS PULLUP_P_BLEED_0 1.39678e-17
C2104 TERM_P_R PULLUP_N_BLEED_5 9.36835e-19
C2105 TERM_VCM DIV_P 1.32183e-16
C2106 VDD PULLUP_P_BLEED_1 3.71e-18
C2107 DIV_ENABLE FS_HIGH_P 4.86815e-15
C2108 FS_P_BLEED_1 PULLUP_P_GATE 9.16675e-20
C2109 TERM_P_R HS_P_8 8.29638e-17
C2110 TERM_ENABLE FS_N_BLEED_5 1.1535e-16
C2111 TERM_OR_P_B HS_P 9.16953e-17
C2112 TERM_N_R PULLDOWN_P 3.16037e-16
C2113 HS_N_10 TERM_OR_N_B 3.02657e-17
C2114 TERM_VCM HS_N_3 1.24535e-16
C2115 PAD_N HS_P_0 3.83123e-16
C2116 HS_N_10 TERM_GATE_P 1.09029e-16
C2117 HS_P_12 FS_LOW_P 1.7418e-16
C2118 DIV_ENABLE FS_P_BLEED_2 1.37454e-17
C2119 HS_N FS_P_GATE 2.28325e-15
C2120 FS_N_OUT VCM_LOW_OK 6.16744e-17
C2121 HS_N_12 HS_P_6 5.90623e-17
C2122 PAD_N TERM_N_R 8.9086e-17
C2123 FS_N_BLEED_0 FS_HIGH_N 9.64337e-18
C2124 HS_N_0 FS_LOW_N 4.60839e-17
C2125 HS_N_4 PULLUP_P_BLEED_5 5.2499e-17
C2126 FS_N_BLEED_6 TERM_P_R 4.76598e-17
C2127 HS_P_3 HS_N_1 2.59854e-17
C2128 TERM_P_R HS_P_7 8.3435e-17
C2129 HS_N HS_P_5 3.9228e-16
C2130 TERM_GATE_N_BLEED_1 HS_N_9 3.48887e-17
C2131 HS_N_0 HS_N_11 3.96402e-17
C2132 HS_N_5 TERM_OR_P_NS 2.58302e-18
C2133 HS_N_2 PULLDOWN_P_R 2.40376e-17
C2134 HS_N_2 FS_P_BLEED_6 6.1779e-17
C2135 HS_N_12 PULLUP_P_CONTROL_S 3.48887e-17
C2136 HS_N_4 PULLUP_P_GATE 7.21128e-17
C2137 HS_N_8 VCM_LOW_OK 3.58883e-17
C2138 HS_N_6 PULLUP_P_BLEED_6 3.30612e-17
C2139 FS_P_WELL PULLDOWN_P_R 3.3755e-15
C2140 TERM_P_R PULLUP_N_BLEED_4 9.36835e-19
C2141 DIV_N VCM_LOW_OK 4.31015e-19
C2142 PAD_P HS_P_0 1.64024e-15
C2143 HS_N_0 PULLUP_P_OUT 2.6893e-17
C2144 FS_P_GATE FS_LOW_P 4.81147e-16
C2145 TERM_OR_P_S PULLUP_P_OUT 4.40679e-18
C2146 FS_P_BLEED_1 PULLDOWN_P_R 1.01235e-16
C2147 HS_N HS_P_8 1.90156e-16
C2148 HS_N_1 FS_HIGH_P 4.92315e-19
C2149 HS_N_12 TERM_OR_N_B 2.94444e-17
C2150 TERM_VCM HS_N_5 1.27528e-16
C2151 VDD PULLUP_P_BLEED_3 5.24075e-16
C2152 TERM_N_R PAD_P 1.88678e-16
C2153 HS_N_12 TERM_GATE_P 1.08145e-16
C2154 PULLUP_N_OUT PULLUP_P_BLEED_4 5.47208e-17
C2155 PAD_N HS_P_4 2.77347e-16
C2156 HS_P_5 FS_LOW_P 1.73406e-16
C2157 HS_PBIAS FS_P_BLEED_5 9.92609e-17
C2158 HS_N_1 FS_P_BLEED_2 3.47206e-17
C2159 FS_N_CONTROL_S TERM_ENABLE 7.64375e-17
C2160 HS_N_2 HS_P_6 5.87551e-17
C2161 FS_N_GATE FS_HIGH_N 5.97522e-15
C2162 TERM_P_R HS_P_9 1.15683e-16
C2163 FS_N_BLEED_6 HS_N 6.15064e-17
C2164 HS_N HS_P_7 1.51318e-16
C2165 TERM_GATE_N_BLEED_1 FS_LOW_N 7.12673e-17
C2166 HS_N_6 PULLUP_P_BLEED_5 5.2499e-17
C2167 TERM_GATE_N_BLEED_1 HS_N_11 3.48887e-17
C2168 TERM_GATE_N_BLEED_2 HS_N_9 5.2499e-17
C2169 HS_N_0 HS_N_13 7.74685e-17
C2170 HS_P_8 FS_LOW_P 4.566e-17
C2171 HS_N_4 FS_P_BLEED_6 6.1779e-17
C2172 HS_N_7 TERM_OR_P_NS 4.91469e-18
C2173 TERM_ENABLE DIFF_ENABLE 3.35499e-17
C2174 HS_N_1 HS_P_10 3.47966e-17
C2175 HS_N_4 PULLDOWN_P_R 2.40376e-17
C2176 HS_N_2 PULLUP_P_CONTROL_S 3.48887e-17
C2177 HS_N_8 PULLUP_P_BLEED_6 4.18833e-17
C2178 HS_N_6 PULLUP_P_GATE 7.4292e-17
C2179 PAD_P HS_P_4 1.13663e-15
C2180 HS_P FS_P_BLEED_4 8.80433e-17
C2181 BYPASS_ENABLE DIFF_ENABLE 6.50064e-15
C2182 VDD HS_N_0 4.92227e-15
C2183 HS_N_2 TERM_OR_N_B 2.90536e-17
C2184 TERM_VCM HS_N_7 1.84464e-16
C2185 VDD TERM_OR_P_S 4.39982e-15
C2186 HS_N_2 TERM_GATE_P 1.07473e-16
C2187 PULLUP_N_BLEED_2 FS_HIGH_P 1.34735e-17
C2188 HS_P_7 FS_LOW_P 4.566e-17
C2189 HS_N_10 FS_P_BLEED_5 6.1779e-17
C2190 FS_N_OUT PULLUP_P_BLEED_5 6.3758e-17
C2191 FS_N_BLEED_6 FS_LOW_P 1.81426e-16
C2192 HS_N_9 TERM_ENABLE 4.80752e-17
C2193 PULLUP_N_WELL FS_N_BLEED_3 6.74983e-19
C2194 HS_N_4 HS_P_6 5.99014e-17
C2195 FS_N_OUT PULLUP_P_GATE 5.08233e-17
C2196 HS_N_0 DIV_P 3.38809e-17
C2197 FS_N_BLEED_0 FS_N_WELL 3.87093e-16
C2198 FS_N_GATE HS_PBIAS 2.74154e-15
C2199 TERM_GATE_N_BLEED_2 FS_LOW_N 8.39001e-17
C2200 TERM_OR_P_B FS_P_OUT 1.61216e-16
C2201 HS_N_8 PULLUP_P_BLEED_5 5.2499e-17
C2202 HS_N HS_P_9 1.21888e-16
C2203 TERM_P_R HS_P_11 1.48523e-16
C2204 TERM_GATE_N_BLEED_1 HS_N_13 3.48887e-17
C2205 HS_N_0 HS_N_3 7.84243e-17
C2206 PULLUP_N_WELL DIV_ENABLE 2.58322e-17
C2207 HS_P HS_P_13 7.10071e-16
C2208 TERM_GATE_N_BLEED_2 HS_N_11 5.26622e-17
C2209 HS_N_6 PULLDOWN_P_R 2.40376e-17
C2210 PULLDOWN_N_R HS_P_2 7.21687e-17
C2211 HS_N_6 FS_P_BLEED_6 6.1779e-17
C2212 HS_N_4 PULLUP_P_CONTROL_S 3.48887e-17
C2213 DIV_N PULLUP_P_BLEED_5 6.00678e-19
C2214 HS_N_8 PULLUP_P_GATE 7.58493e-17
C2215 PULLUP_N_WELL PULLUP_N_BLEED_3 1.99646e-18
C2216 DIV_N PULLUP_P_GATE 1.34827e-18
C2217 VDD TERM_GATE_N_BLEED_1 4.51879e-16
C2218 HS_N_4 TERM_OR_N_B 2.84614e-17
C2219 TERM_VCM DIV_ENABLE 2.24901e-16
C2220 HS_N_4 TERM_GATE_P 1.12175e-16
C2221 PULLUP_P TERM_GATE_N 2.62957e-16
C2222 HS_P_9 FS_LOW_P 5.65665e-17
C2223 HS_N_12 FS_P_BLEED_5 6.1779e-17
C2224 FS_LOW_N TERM_ENABLE 2.377e-16
C2225 PULLUP_N_OUT PULLUP_P_BLEED_2 4.04393e-19
C2226 FS_HIGH_N HS_P 3.74305e-17
C2227 HS_N_11 TERM_ENABLE 4.83039e-17
C2228 PULLDOWN_N_R TERM_GATE_N 1.54013e-16
C2229 FS_N_OUT FS_P_BLEED_6 4.87706e-17
C2230 HS_N DIV_LOW_N 8.85647e-17
C2231 FS_LOW_N FS_N_BLEED_5 2.0817e-19
C2232 HS_P HS_P_1 4.17389e-15
C2233 FS_N_GATE FS_N_WELL 2.95427e-13
C2234 HS_N_6 HS_P_6 6.9385e-17
C2235 FS_N_GATE HS_N_10 2.12997e-17
C2236 HS_N HS_P_11 6.68797e-16
C2237 PULLUP_P_WELL PULLUP_P_BLEED_4 2.57363e-18
C2238 TERM_GATE_N_BLEED_1 HS_N_3 3.48887e-17
C2239 TERM_GATE_N_BLEED_2 HS_N_13 5.2499e-17
C2240 HS_N_0 HS_N_5 3.91118e-17
C2241 PULLUP_N_OUT HS_P_3 8.63334e-17
C2242 HS_N_8 FS_P_BLEED_6 6.1779e-17
C2243 TERM_ENABLE PULLUP_P_OUT 1.15152e-14
C2244 HS_N_8 PULLDOWN_P_R 2.40376e-17
C2245 PULLDOWN_N_R TERM_OR_P_B 1.69541e-16
C2246 HS_N_6 PULLUP_P_CONTROL_S 3.48887e-17
C2247 FS_N_BLEED_2 FS_HIGH_P 4.04393e-19
C2248 TERM_P_R PULLUP_N_BLEED_1 4.76598e-17
C2249 TERM_VCM TERM_GATE_N_BLEED_0 1.18622e-16
C2250 PULLUP_N_BLEED_0 PULLUP_N_CONTROL_S 5.53351e-18
C2251 DIV_LOW_N FS_LOW_P 8.85647e-17
C2252 TERM_ENABLE FS_N_BLEED_4 8.9543e-17
C2253 FS_N_OUT HS_P_6 6.16744e-17
C2254 HS_N_6 TERM_OR_N_B 2.84614e-17
C2255 TERM_VCM HS_N_1 1.64345e-16
C2256 FS_N_BLEED_5 FS_N_BLEED_4 7.71303e-15
C2257 VCM_LOW_OK PULLUP_P_GATE 3.49387e-16
C2258 HS_N_6 TERM_GATE_P 1.17846e-16
C2259 HS_N_2 FS_P_BLEED_5 6.1779e-17
C2260 PULLUP_N_CONTROL_S HS_P 3.22793e-17
C2261 HS_P_11 FS_LOW_P 5.23872e-17
C2262 FS_N_BLEED_1 HS_N 7.09674e-17
C2263 PULLUP_N_OUT FS_P_BLEED_2 6.15064e-17
C2264 HS_N_13 TERM_ENABLE 8.85304e-17
C2265 HS_PBIAS HS_P 1.6547e-13
C2266 HS_N_8 HS_P_6 4.80752e-17
C2267 FS_N_OUT PULLUP_P_CONTROL_S 6.16744e-17
C2268 HS_P_2 HS_P_12 2.0615e-18
C2269 FS_N_GATE HS_N_12 2.56664e-17
C2270 PULLDOWN_P PULLUP_P_BLEED_4 2.16295e-19
C2271 DIV_N HS_P_6 4.31015e-19
C2272 TERM_P_R HS_P_0 7.62563e-17
C2273 TERM_GATE_N_BLEED_1 HS_N_5 3.48887e-17
C2274 TERM_GATE_N_BLEED_2 HS_N_3 5.2499e-17
C2275 HS_N_0 HS_N_7 7.11334e-17
C2276 HS_N_8 PULLUP_P_CONTROL_S 3.48887e-17
C2277 VDD TERM_ENABLE 1.47303e-14
C2278 HS_N_6 PULLUP_P_BLEED_0 4.38619e-19
C2279 HS_N PULLUP_N_BLEED_1 6.16744e-17
C2280 TERM_P_R TERM_N_R 3.54953e-14
C2281 PULLUP_N_OUT HS_P_10 8.96075e-17
C2282 PULLUP_N_WELL PULLUP_N_BLEED_2 1.13798e-17
C2283 RX_P HS_P_0 2.06839e-20
C2284 FS_N_OUT TERM_GATE_P 1.12498e-16
C2285 DIV_N PULLUP_P_CONTROL_S 4.31015e-19
C2286 VDD FS_N_BLEED_5 5.54309e-16
C2287 FS_N_BLEED_1 FS_LOW_P 2.37672e-16
C2288 FS_LOW_N DIFF_ENABLE 2.52569e-16
C2289 PULLUP_P_BLEED_6 PULLUP_P_BLEED_5 4.72363e-15
C2290 HS_N_8 TERM_OR_N_B 2.8794e-17
C2291 HS_P_13 FS_P_OUT 1.27501e-16
C2292 VDD BYPASS_ENABLE 4.51573e-17
C2293 VCM_LOW_OK PULLDOWN_P_R 6.55349e-17
C2294 PULLUP_P_BLEED_6 PULLUP_P_GATE 3.36504e-15
C2295 HS_N_8 TERM_GATE_P 1.28047e-16
C2296 HS_N_4 FS_P_BLEED_5 6.1779e-17
C2297 FS_N_WELL HS_P 2.924e-15
C2298 HS_N_3 TERM_ENABLE 4.80752e-17
C2299 HS_N_10 HS_P 2.07358e-16
C2300 DIV_N TERM_GATE_P 1.77929e-18
C2301 PULLUP_N_BLEED_1 FS_LOW_P 6.27135e-17
C2302 HS_P_2 HS_P_5 3.14179e-17
C2303 TERM_OR_P_B HS_P_12 1.30594e-16
C2304 TERM_P_R HS_P_4 1.25403e-16
C2305 BYPASS_ENABLE DIV_P 5.9579e-17
C2306 HS_N HS_P_0 5.49057e-16
C2307 TERM_GATE_N_BLEED_1 HS_N_7 3.48887e-17
C2308 TERM_GATE_N_BLEED_2 HS_N_5 5.2499e-17
C2309 FS_LOW_N HS_N_9 8.74721e-17
C2310 HS_N_0 DIV_ENABLE 1.72358e-15
C2311 PULLUP_P_WELL PULLUP_P_BLEED_2 1.20134e-16
C2312 HS_N_9 HS_N_11 3.51103e-17
C2313 HS_N TERM_N_R 2.79477e-16
C2314 HS_N_8 PULLUP_P_BLEED_0 7.58005e-19
C2315 HS_P_6 VCM_LOW_OK 3.48887e-17
C2316 TERM_VCM TERM_GATE_P_BLEED_2 2.19364e-17
C2317 HS_P_2 HS_P_8 3.10308e-17
C2318 TERM_OR_N_S FS_HIGH_P 3.69142e-18
C2319 HS_N_9 PULLUP_P_OUT 2.40376e-17
C2320 PULLUP_P_GATE PULLUP_P_BLEED_5 1.47587e-16
C2321 VDD FS_N_CONTROL_S 7.07839e-16
C2322 VCM_LOW_OK PULLUP_P_CONTROL_S 3.76229e-17
C2323 PULLUP_P_BLEED_6 PULLDOWN_P_R 9.39536e-17
C2324 HS_P_0 FS_LOW_P 9.31951e-17
C2325 HS_N_6 FS_P_BLEED_5 6.23109e-17
C2326 PULLDOWN_N_R HS_P_13 2.40376e-17
C2327 HS_N_5 TERM_ENABLE 4.80752e-17
C2328 HS_N_12 HS_P 7.85887e-16
C2329 PULLUP_N_WELL FS_N_BLEED_2 6.74983e-19
C2330 PULLUP_P_WELL FS_HIGH_P 2.75853e-16
C2331 HS_P_2 HS_P_7 6.18445e-17
C2332 TERM_OR_P_B HS_P_5 1.01557e-16
C2333 TERM_N_R FS_LOW_P 2.27359e-16
C2334 VCM_LOW_OK TERM_OR_N_B 4.35323e-15
C2335 HS_N HS_P_4 1.58774e-16
C2336 TERM_P_R TERM_GATE_P_BLEED_0 2.57363e-18
C2337 TERM_GATE_N_BLEED_2 HS_N_7 5.2499e-17
C2338 HS_N_0 HS_N_1 1.24629e-13
C2339 PULLUP_N_WELL PULLUP_N_OUT 3.25189e-14
C2340 TERM_GATE_N_BLEED_1 DIV_ENABLE 1.37454e-17
C2341 FS_LOW_N HS_N_11 4.60726e-17
C2342 FS_P_BLEED_2 PULLUP_P_WELL 5.42183e-18
C2343 TERM_GATE_P VCM_LOW_OK 2.01883e-16
C2344 HS_N_9 HS_N_13 1.5155e-16
C2345 PULLUP_N_OUT TERM_OR_P_NS 1.1021e-16
C2346 HS_PBIAS FS_P_OUT 9.82031e-16
C2347 FS_HIGH_N PULLUP_P 4.37656e-17
C2348 TERM_OR_P_B HS_P_8 1.00574e-16
C2349 FS_P_BLEED_5 FS_N_OUT 5.62374e-17
C2350 PULLUP_N PULLUP_N_CONTROL_S 1.77933e-15
C2351 FS_HIGH_N PULLDOWN_N_R 3.74305e-17
C2352 PULLDOWN_P_R PULLUP_P_BLEED_5 9.20433e-17
C2353 HS_N_11 PULLUP_P_OUT 2.5076e-17
C2354 HS_PBIAS PULLUP_N 2.68187e-17
C2355 PULLDOWN_N_R HS_P_1 6.54378e-17
C2356 PULLUP_N_OUT TERM_VCM 5.07356e-16
C2357 PULLUP_P_GATE PULLDOWN_P_R 2.4897e-16
C2358 FS_P_BLEED_6 PULLUP_P_GATE 6.11597e-17
C2359 VDD HS_N_9 5.06755e-15
C2360 PAD_N HS_P_3 2.56999e-16
C2361 HS_P_4 FS_LOW_P 4.59929e-17
C2362 HS_N_8 FS_P_BLEED_5 6.26589e-17
C2363 HS_N_7 TERM_ENABLE 1.03322e-16
C2364 FS_LOW_N FS_N_BLEED_4 2.82661e-19
C2365 HS_N_2 HS_P 8.52929e-16
C2366 FS_P_WELL HS_P 2.05815e-15
C2367 TERM_GATE_N_BLEED_1 TERM_GATE_N_BLEED_0 2.88199e-15
C2368 HS_P_2 HS_P_9 4.19e-17
C2369 FS_P_BLEED_1 HS_P 6.1779e-17
C2370 TERM_OR_P_B HS_P_7 1.01166e-16
C2371 PULLUP_N_OUT PULLUP_P_BLEED_1 4.64285e-17
C2372 FS_LOW_N HS_N_13 4.57398e-17
C2373 TERM_GATE_N_BLEED_1 HS_N_1 3.48887e-17
C2374 TERM_GATE_N_BLEED_2 DIV_ENABLE 2.67272e-19
C2375 HS_N_9 HS_N_3 3.33161e-18
C2376 HS_PBIAS PULLUP_P 3.12738e-16
C2377 HS_PBIAS FS_P_CONTROL_S 4.86088e-17
C2378 HS_N_10 FS_P_OUT 4.42486e-16
C2379 PULLUP_N_CONTROL_S PULLUP_P 1.10536e-18
C2380 HS_N_11 HS_N_13 1.05138e-16
C2381 HS_P_3 PAD_P 1.68578e-15
C2382 PULLDOWN_N_R PULLUP_N_CONTROL_S 3.76421e-17
C2383 FS_HIGH_N PULLUP_N_GATE 2.61883e-18
C2384 HS_PBIAS PULLDOWN_N_R 7.7848e-16
C2385 HS_N_13 PULLUP_P_OUT 2.4636e-17
C2386 VDD FS_LOW_N 1.92499e-15
C2387 TERM_ENABLE FS_N_BLEED_3 1.16848e-17
C2388 HS_P_13 HS_P_12 4.70352e-14
C2389 FS_N_GATE FS_N_OUT 1.51029e-13
C2390 VDD HS_N_11 6.23318e-15
C2391 FS_P_BLEED_3 FS_HIGH_P 3.57681e-17
C2392 FS_P_BLEED_4 FS_P_GATE 2.93237e-16
C2393 FS_P_BLEED_6 PULLDOWN_P_R 1.12546e-16
C2394 PULLDOWN_N TERM_VCM 4.2801e-17
C2395 FS_N_BLEED_5 FS_N_BLEED_3 1.06333e-16
C2396 PULLUP_P_GATE PULLUP_P_CONTROL_S 1.59532e-15
C2397 HS_N_4 HS_P 3.25189e-16
C2398 DIV_ENABLE TERM_ENABLE 3.19248e-17
C2399 FS_P_BLEED_2 FS_P_BLEED_3 1.49098e-15
C2400 TERM_GATE_N_BLEED_2 TERM_GATE_N_BLEED_0 3.06736e-19
C2401 VDD PULLUP_P_OUT 4.02871e-15
C2402 TERM_OR_P_B HS_P_9 1.442e-16
C2403 HS_P_2 HS_P_11 1.05682e-18
C2404 FS_N_GATE HS_N_8 6.84656e-20
C2405 PAD_N HS_P_10 4.24765e-16
C2406 FS_LOW_N HS_N_3 4.57398e-17
C2407 TERM_GATE_N_BLEED_2 HS_N_1 5.28587e-17
C2408 HS_N_10 FS_P_CONTROL_S 3.2364e-17
C2409 HS_PBIAS FS_P_BLEED_0 8.85647e-17
C2410 HS_N_9 HS_N_5 4.07931e-17
C2411 HS_N_12 FS_P_OUT 4.38013e-16
C2412 HS_N_11 HS_N_3 6.43885e-17
C2413 FS_N_WELL PULLUP_P 1.97293e-15
C2414 BYPASS_ENABLE DIV_ENABLE 7.45289e-14
C2415 PULLUP_N_OUT PULLUP_P_BLEED_3 2.82661e-19
C2416 HS_P_6 PULLDOWN_P_R 2.40376e-17
C2417 HS_P_1 HS_P_12 5.93509e-17
C2418 PULLDOWN_N_R FS_N_WELL 2.2767e-15
C2419 VDD FS_N_BLEED_4 1.56976e-17
C2420 FS_P_GATE HS_P_13 2.47794e-16
C2421 PULLUP_N_GATE PULLUP_N_CONTROL_S 1.19294e-15
C2422 DIV_LOW_N TERM_GATE_N 2.98455e-17
C2423 HS_N_10 PULLDOWN_N_R 2.40376e-17
C2424 HS_N_3 PULLUP_P_OUT 2.40376e-17
C2425 HS_PBIAS PULLUP_N_GATE 1.6144e-16
C2426 PULLUP_P_BLEED_0 PULLUP_P_BLEED_5 5.4639e-19
C2427 HS_P_13 HS_P_5 2.69283e-16
C2428 TERM_VCM TERM_OR_N_S 6.06589e-19
C2429 TERM_ENABLE TERM_GATE_N_BLEED_0 2.0615e-18
C2430 PULLDOWN_P_R PULLUP_P_CONTROL_S 5.46167e-17
C2431 TERM_P_R PULLUP_P_BLEED_4 4.76598e-17
C2432 PAD_P HS_P_10 1.26307e-15
C2433 VDD HS_N_13 6.76594e-15
C2434 PULLUP_P_GATE PULLUP_P_BLEED_0 5.11673e-17
C2435 HS_N_6 HS_P 1.04391e-15
C2436 HS_N_1 TERM_ENABLE 1.06073e-16
C2437 TERM_OR_P_B HS_P_11 1.19377e-16
C2438 TERM_VCM PULLUP_P_WELL 3.82833e-16
C2439 HS_P_13 HS_P_8 5.62374e-17
C2440 FS_LOW_N HS_N_5 4.57398e-17
C2441 TERM_GATE_P PULLDOWN_P_R 3.01434e-16
C2442 PULLUP_N_OUT HS_N_0 5.06175e-17
C2443 HS_N_12 FS_P_CONTROL_S 3.22599e-17
C2444 HS_N_10 FS_P_BLEED_0 6.1779e-17
C2445 HS_N_11 HS_N_5 2.82661e-19
C2446 HS_N_9 HS_N_7 4.1513e-17
C2447 HS_N_2 FS_P_OUT 4.35755e-16
C2448 HS_N_13 HS_N_3 3.08942e-16
C2449 HS_N_12 PULLUP_P 6.95504e-19
C2450 FS_P_WELL FS_P_OUT 2.10282e-13
C2451 HS_PBIAS HS_P_12 4.10448e-15
C2452 HS_P_1 HS_P_5 2.41139e-17
C2453 PULLUP_P_WELL PULLUP_P_BLEED_1 1.22853e-16
C2454 VDD DIV_P 1.11676e-16
C2455 HS_N_12 PULLDOWN_N_R 6.1589e-17
C2456 FS_N_OUT HS_P 7.63245e-16
C2457 PULLUP_N_WELL PULLDOWN_P 4.31987e-16
C2458 HS_N_5 PULLUP_P_OUT 2.40376e-17
C2459 DIV_ENABLE DIFF_ENABLE 6.75692e-15
C2460 HS_P_13 HS_P_7 1.42039e-16
C2461 VDD HS_N_3 5.42295e-15
C2462 TERM_ENABLE TERM_GATE_P_BLEED_1 1.03191e-16
C2463 HS_N PULLUP_P_BLEED_4 4.82815e-17
C2464 PULLDOWN_P_R PULLUP_P_BLEED_0 1.24089e-16
C2465 HS_N_8 HS_P 5.9635e-16
C2466 HS_P_6 TERM_GATE_P 1.55077e-16
C2467 HS_P_8 HS_P_1 2.40376e-17
C2468 TERM_VCM PULLDOWN_P 1.85479e-16
C2469 DIV_N HS_P 3.58115e-17
C2470 HS_N_3 DIV_P 3.38809e-17
C2471 HS_P_2 HS_P_0 4.31219e-18
C2472 HS_PBIAS FS_P_GATE 1.89121e-15
C2473 FS_LOW_N HS_N_7 4.57398e-17
C2474 PULLUP_N_OUT TERM_GATE_N_BLEED_1 5.46167e-17
C2475 HS_N_10 HS_P_12 7.70877e-17
C2476 HS_N_4 FS_P_OUT 4.33306e-16
C2477 HS_N_2 FS_P_CONTROL_S 3.22599e-17
C2478 HS_N_12 FS_P_BLEED_0 6.1779e-17
C2479 HS_N_9 DIV_ENABLE 3.08895e-17
C2480 HS_N_13 HS_N_5 1.03866e-16
C2481 HS_N_11 HS_N_7 2.98539e-17
C2482 FS_N_BLEED_6 FS_HIGH_N 1.66096e-16
C2483 FS_P_BLEED_5 PULLUP_P_GATE 4.70063e-19
C2484 HS_PBIAS HS_P_5 3.80328e-15
C2485 FS_P_WELL FS_P_CONTROL_S 1.94786e-16
C2486 HS_P_1 HS_P_7 5.96249e-17
C2487 PAD_N TERM_VCM 1.00205e-18
C2488 PULLUP_P_BLEED_4 FS_LOW_P 6.86613e-17
C2489 HS_N_2 PULLDOWN_N_R 2.40376e-17
C2490 FS_P_BLEED_1 FS_P_CONTROL_S 2.75956e-18
C2491 HS_N_7 PULLUP_P_OUT 2.40376e-17
C2492 FS_P_WELL PULLDOWN_N_R 2.76564e-15
C2493 HS_P_13 HS_P_9 4.87706e-17
C2494 TERM_ENABLE TERM_GATE_P_BLEED_2 7.30603e-17
C2495 PULLUP_P_BLEED_3 PULLUP_P_WELL 4.57221e-19
C2496 PULLUP_P_CONTROL_S PULLUP_P_BLEED_0 6.85274e-19
C2497 VDD HS_N_5 6.45763e-15
C2498 PULLDOWN_N_R FS_P_BLEED_1 1.01235e-16
C2499 HS_PBIAS HS_P_8 1.54227e-15
C2500 FS_LOW_N FS_N_BLEED_3 4.04393e-19
C2501 TERM_N_R TERM_GATE_N 2.76669e-14
C2502 TERM_P_R PULLUP_P_BLEED_2 4.58761e-17
C2503 TERM_OR_P_B HS_P_0 9.38414e-17
C2504 HS_P_2 HS_P_4 3.98637e-17
C2505 HS_N_10 FS_P_GATE 1.02198e-15
C2506 TERM_VCM PAD_P 2.70139e-18
C2507 HS_N_0 TERM_OR_N_S 6.38433e-17
C2508 FS_LOW_N DIV_ENABLE 3.50968e-17
C2509 TERM_P_R HS_P_3 1.21358e-16
C2510 PULLUP_N_OUT TERM_GATE_N_BLEED_2 9.19551e-17
C2511 FS_P_BLEED_5 FS_P_BLEED_6 3.5401e-15
C2512 FS_P_BLEED_5 PULLDOWN_P_R 8.55331e-17
C2513 TERM_N_R TERM_OR_P_B 1.12426e-15
C2514 HS_N_10 HS_P_5 3.48887e-17
C2515 HS_N_12 HS_P_12 8.27225e-17
C2516 HS_N_6 FS_P_OUT 4.33306e-16
C2517 HS_N_4 FS_P_CONTROL_S 3.22599e-17
C2518 HS_N_2 FS_P_BLEED_0 6.1779e-17
C2519 HS_N_9 HS_N_1 4.2943e-17
C2520 HS_N_3 HS_N_5 2.0615e-18
C2521 FS_N_BLEED_6 HS_PBIAS 4.81135e-17
C2522 HS_N_13 HS_N_7 9.54629e-17
C2523 HS_PBIAS HS_P_7 7.84988e-16
C2524 HS_P VCM_LOW_OK 4.3124e-17
C2525 FS_P_WELL FS_P_BLEED_0 4.87941e-15
C2526 HS_N_11 DIV_ENABLE 3.16132e-17
C2527 HS_P_1 HS_P_9 3.49441e-17
C2528 HS_N_4 PULLDOWN_N_R 2.40376e-17
C2529 HS_PBIAS PULLUP_N_BLEED_4 1.6332e-17
C2530 FS_P_BLEED_1 FS_P_BLEED_0 7.1724e-15
C2531 TERM_P_R FS_HIGH_P 1.00821e-17
C2532 HS_N_0 PULLUP_P_WELL 3.82307e-16
C2533 HS_P_13 HS_P_11 8.85142e-17
C2534 VDD HS_N_7 6.97232e-15
C2535 FS_N_BLEED_4 FS_N_BLEED_3 6.17691e-15
C2536 FS_N_BLEED_5 FS_N_BLEED_2 1.05588e-16
C2537 TERM_P_R FS_P_BLEED_2 4.76598e-17
C2538 PULLUP_N_OUT TERM_ENABLE 1.92431e-16
C2539 FS_N_OUT FS_P_OUT 1.00131e-15
C2540 PULLUP_N_OUT FS_N_BLEED_5 1.01235e-16
C2541 TERM_OR_P_B HS_P_4 1.0189e-16
C2542 HS_N_12 FS_P_GATE 1.01722e-15
C2543 HS_P_2 TERM_GATE_P_BLEED_0 2.48309e-17
C2544 HS_N HS_P_3 2.78033e-16
C2545 TERM_VCM DIV_LOW_P 2.57067e-18
C2546 FS_N_BLEED_6 FS_N_WELL 6.3693e-18
C2547 FS_LOW_N HS_N_1 4.62644e-17
C2548 HS_N_12 HS_P_5 3.48887e-17
C2549 HS_N_2 HS_P_12 6.57781e-17
C2550 HS_N_6 FS_P_CONTROL_S 3.22599e-17
C2551 HS_N_4 FS_P_BLEED_0 6.1779e-17
C2552 HS_N_13 DIV_ENABLE 3.08895e-17
C2553 HS_N_11 HS_N_1 7.58432e-17
C2554 HS_N_3 HS_N_7 2.87722e-17
C2555 HS_N_8 FS_P_OUT 4.33669e-16
C2556 HS_PBIAS HS_P_9 3.39603e-15
C2557 HS_P PULLUP_P_BLEED_6 1.02136e-16
C2558 HS_N_6 PULLUP_P 4.37656e-17
C2559 DIV_N FS_P_OUT 6.9541e-17
C2560 TERM_P_R HS_P_10 1.42285e-16
C2561 FS_P_WELL HS_P_12 1.31511e-17
C2562 HS_P_1 HS_P_11 5.93509e-17
C2563 TERM_N_R TERM_OR_N_NS 3.61354e-18
C2564 HS_N_0 PULLDOWN_P 4.42824e-17
C2565 HS_N_6 PULLDOWN_N_R 6.83199e-17
C2566 HS_N_1 PULLUP_P_OUT 2.59854e-17
C2567 HS_N FS_HIGH_P 9.39679e-19
C2568 VDD DIV_ENABLE 1.46286e-16
C2569 HS_P_3 FS_LOW_P 4.60724e-17
C2570 HS_N FS_P_BLEED_2 4.40453e-17
C2571 PAD_N HS_N_0 1.42664e-15
C2572 FS_N_BLEED_1 FS_HIGH_N 4.04393e-19
C2573 PULLDOWN_N TERM_ENABLE 6.10321e-17
C2574 FS_N_OUT FS_P_CONTROL_S 6.62605e-18
C2575 HS_N_2 FS_P_GATE 1.01182e-15
C2576 FS_N_OUT PULLUP_P 4.66023e-16
C2577 TERM_OR_P_B TERM_GATE_P_BLEED_0 4.79522e-18
C2578 FS_P_WELL FS_P_GATE 2.63581e-13
C2579 HS_PBIAS DIV_LOW_N 1.04595e-16
C2580 DIV_ENABLE DIV_P 4.76769e-15
C2581 HS_P PULLUP_P_BLEED_5 5.2499e-17
C2582 FS_N_OUT PULLDOWN_N_R 6.08223e-16
C2583 FS_P_BLEED_1 FS_P_GATE 1.63747e-16
C2584 HS_N_0 FS_P_BLEED_3 6.61586e-19
C2585 HS_N_2 HS_P_5 3.48887e-17
C2586 FS_HIGH_P FS_LOW_P 8.66124e-15
C2587 HS_N_6 FS_P_BLEED_0 6.1779e-17
C2588 HS_N_3 DIV_ENABLE 3.08895e-17
C2589 HS_N_8 PULLUP_P 5.06175e-17
C2590 PULLUP_N_OUT FS_N_CONTROL_S 1.04601e-16
C2591 HS_N_8 FS_P_CONTROL_S 3.23809e-17
C2592 HS_N_13 HS_N_1 9.08543e-17
C2593 HS_N_4 HS_P_12 7.18129e-17
C2594 HS_N_5 HS_N_7 7.79839e-17
C2595 FS_LOW_N PULLUP_N_BLEED_2 8.38863e-17
C2596 HS_P PULLUP_P_GATE 7.93995e-17
C2597 HS_PBIAS HS_P_11 9.38284e-15
C2598 HS_N HS_P_10 3.44984e-16
C2599 PULLUP_P_OUT TERM_GATE_P_BLEED_1 1.4929e-16
C2600 VDD TERM_GATE_N_BLEED_0 9.72156e-16
C2601 TERM_GATE_N_BLEED_1 PULLDOWN_P 4.82815e-17
C2602 HS_N_8 PULLDOWN_N_R 6.83199e-17
C2603 HS_N_0 PAD_P 1.45583e-16
C2604 FS_HIGH_N PULLUP_N_BLEED_1 1.66028e-16
C2605 FS_P_BLEED_2 FS_LOW_P 7.13946e-17
C2606 PULLDOWN_N_R DIV_N 4.20197e-17
C2607 HS_P_13 HS_P_0 1.89914e-17
C2608 VDD HS_N_1 5.26905e-15
C2609 VCM_LOW_OK FS_P_OUT 4.1274e-16
C2610 TERM_OR_N_S TERM_ENABLE 7.06942e-15
C2611 FS_N_OUT FS_P_BLEED_0 2.84794e-16
C2612 FS_N_BLEED_1 HS_PBIAS 7.79762e-17
C2613 HS_N_4 FS_P_GATE 1.011e-15
C2614 HS_P_10 FS_LOW_P 5.50896e-17
C2615 HS_N_10 DIV_LOW_N 6.1779e-17
C2616 PULLUP_N_WELL TERM_P_R 2.52823e-16
C2617 TERM_P_R TERM_OR_P_NS 2.25891e-16
C2618 HS_N_4 HS_P_5 3.51065e-17
C2619 HS_N_6 HS_P_12 6.57781e-17
C2620 HS_N_8 FS_P_BLEED_0 6.1779e-17
C2621 HS_P FS_P_BLEED_6 6.1779e-17
C2622 HS_N_5 DIV_ENABLE 3.08895e-17
C2623 HS_N_3 HS_N_1 8.22555e-17
C2624 HS_N_10 HS_P_11 3.50619e-18
C2625 TERM_ENABLE PULLUP_P_WELL 2.3244e-15
C2626 HS_P PULLDOWN_P_R 3.04764e-17
C2627 PULLUP_N_OUT HS_N_9 1.49245e-17
C2628 PULLUP_P_OUT TERM_GATE_P_BLEED_2 4.24183e-17
C2629 HS_P_1 HS_P_0 3.64065e-14
C2630 VDD TERM_GATE_P_BLEED_1 7.12118e-17
C2631 TERM_GATE_N_BLEED_2 PULLDOWN_P 7.92848e-17
C2632 HS_PBIAS PULLUP_N_BLEED_1 4.82815e-17
C2633 PULLUP_N_BLEED_1 PULLUP_N_CONTROL_S 5.14019e-19
C2634 FS_HIGH_N TERM_N_R 9.51731e-17
C2635 HS_P_13 HS_P_4 1.44632e-16
C2636 BYPASS_ENABLE PULLUP_P_WELL 8.22717e-18
C2637 PULLDOWN_N DIFF_ENABLE 1.2241e-16
C2638 HS_N_0 DIV_LOW_P 5.84916e-18
C2639 TERM_P_R TERM_VCM 1.97862e-13
C2640 PULLUP_P VCM_LOW_OK 7.11798e-17
C2641 FS_LOW_N FS_N_BLEED_2 6.21526e-19
C2642 VDD PULLUP_N_BLEED_2 3.14506e-19
C2643 FS_N_BLEED_1 FS_N_WELL 4.54977e-18
C2644 FS_N_OUT HS_P_12 1.23349e-16
C2645 PULLDOWN_N_R VCM_LOW_OK 9.09167e-17
C2646 HS_P HS_P_6 3.46603e-15
C2647 HS_N_6 FS_P_GATE 1.02474e-15
C2648 HS_N_12 DIV_LOW_N 6.1779e-17
C2649 PULLUP_N_OUT FS_LOW_N 6.42575e-17
C2650 TERM_ENABLE PULLDOWN_P 3.74305e-17
C2651 PULLUP_N_WELL HS_N 7.15665e-16
C2652 HS_N_8 HS_P_12 6.33501e-17
C2653 HS_P PULLUP_P_CONTROL_S 3.48887e-17
C2654 HS_N_7 DIV_ENABLE 3.08895e-17
C2655 HS_N_5 HS_N_1 4.30193e-17
C2656 HS_N_12 HS_P_11 1.1035e-16
C2657 HS_N_6 HS_P_5 1.43705e-16
C2658 HS_PBIAS HS_P_0 9.48826e-16
C2659 FS_N_BLEED_5 PULLDOWN_P 8.85647e-17
C2660 DIV_N HS_P_12 1.24604e-17
C2661 HS_P_1 HS_P_4 3.20664e-17
C2662 VDD TERM_GATE_P_BLEED_2 8.40041e-17
C2663 HS_PBIAS TERM_N_R 8.22978e-16
C2664 HS_P TERM_OR_N_B 2.90384e-17
C2665 FS_N_OUT FS_P_GATE 3.55763e-16
C2666 PULLUP_N_OUT PULLUP_P_OUT 1.73969e-16
C2667 HS_P_13 TERM_GATE_P_BLEED_0 2.56002e-17
C2668 PULLUP_P PULLUP_P_BLEED_6 1.46943e-16
C2669 HS_N TERM_VCM 2.11606e-16
C2670 FS_N_BLEED_4 FS_N_BLEED_2 1.23091e-16
C2671 VCM_LOW_OK FS_P_BLEED_0 1.46148e-17
C2672 HS_P TERM_GATE_P 2.26214e-16
.ends rx_pad_with_discharge_physical
