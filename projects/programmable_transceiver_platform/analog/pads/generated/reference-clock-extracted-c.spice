* Independent exporter of physical Magic .ext; no schematic substitutions.
* Extracted capacitance included; distributed wire resistance remains absent.
.subckt pad_reference_clock_flat_physical PAD_P PAD_N VSS VCM
X0 PAD_N VSS VSS VSS nfet_06v0_dss w=16u l=0.6u ad=60.48p as=4.48p pd=39.56u ps=32.56u d_sab=3.78u s_sab=0.28u
X1 PAD_N VSS VSS VSS nfet_06v0_dss w=16u l=0.6u ad=60.48p as=4.48p pd=39.56u ps=32.56u d_sab=3.78u s_sab=0.28u
X2 PAD_P VSS VSS VSS nfet_06v0_dss w=16u l=0.6u ad=60.48p as=4.48p pd=39.56u ps=32.56u d_sab=3.78u s_sab=0.28u
X3 PAD_P VSS VSS VSS nfet_06v0_dss w=16u l=0.6u ad=60.48p as=4.48p pd=39.56u ps=32.56u d_sab=3.78u s_sab=0.28u
X4 BIAS_P_5 BIAS_P_4 VSS ppolyf_u_1k r_width=1u r_length=12.5u
X5 BIAS_P_4 BIAS_P_3 VSS ppolyf_u_1k r_width=1u r_length=12.5u
X6 BIAS_P_3 BIAS_P_2 VSS ppolyf_u_1k r_width=1u r_length=12.5u
X7 BIAS_P_2 BIAS_P_1 VSS ppolyf_u_1k r_width=1u r_length=12.5u
X8 BIAS_P_1 BIAS_P_0 VSS ppolyf_u_1k r_width=1u r_length=12.5u
X9 BIAS_P_0 PAD_P VSS ppolyf_u_1k r_width=1u r_length=12.5u
X10 BIAS_N_0 PAD_N VSS ppolyf_u_1k r_width=1u r_length=12.5u
X11 BIAS_N_5 BIAS_N_4 VSS ppolyf_u_1k r_width=1u r_length=12.5u
X12 BIAS_N_4 BIAS_N_3 VSS ppolyf_u_1k r_width=1u r_length=12.5u
X13 BIAS_N_3 BIAS_N_2 VSS ppolyf_u_1k r_width=1u r_length=12.5u
X14 BIAS_N_2 BIAS_N_1 VSS ppolyf_u_1k r_width=1u r_length=12.5u
X15 BIAS_N_1 BIAS_N_0 VSS ppolyf_u_1k r_width=1u r_length=12.5u
X16 VCM BIAS_P_6 VSS ppolyf_u_1k r_width=1u r_length=12.5u
X17 BIAS_P_6 BIAS_P_5 VSS ppolyf_u_1k r_width=1u r_length=12.5u
X18 VCM BIAS_N_6 VSS ppolyf_u_1k r_width=1u r_length=12.5u
X19 BIAS_N_6 BIAS_N_5 VSS ppolyf_u_1k r_width=1u r_length=12.5u
C9 BIAS_P_4 VSS 1.68849e-14
C11 BIAS_P_3 VSS 1.39105e-14
C13 BIAS_P_2 VSS 1.10489e-14
C15 BIAS_P_1 VSS 8.17942e-15
C17 BIAS_P_0 VSS 5.61856e-15
C19 PAD_P VSS 1.74755e-13
C21 PAD_N VSS 1.94791e-13
C23 BIAS_N_4 VSS 1.70152e-14
C25 BIAS_N_3 VSS 1.40185e-14
C27 BIAS_N_2 VSS 1.11732e-14
C29 BIAS_N_1 VSS 8.34242e-15
C31 BIAS_N_0 VSS 6.74563e-15
C33 BIAS_P_6 VSS 4.19511e-15
C35 BIAS_P_5 VSS 1.40052e-14
C36 VCM VSS 1.18895e-14
C38 BIAS_N_6 VSS 4.29492e-15
C40 BIAS_N_5 VSS 1.40325e-14
C41 BIAS_N_1 VCM 9.84558e-17
C42 BIAS_N_3 BIAS_N_5 8.54567e-18
C43 PAD_N BIAS_P_0 1.53925e-16
C44 BIAS_N_1 BIAS_N_5 7.62796e-18
C45 BIAS_P_6 BIAS_P_4 3.06736e-19
C46 BIAS_P_3 BIAS_P_1 1.11596e-16
C47 BIAS_P_2 PAD_P 1.07204e-16
C48 BIAS_P_2 BIAS_P_5 7.80014e-18
C49 BIAS_N_0 PAD_P 3.2895e-18
C50 BIAS_N_0 BIAS_P_5 9.83433e-17
C51 BIAS_P_4 BIAS_P_0 8.66282e-17
C52 PAD_N PAD_P 2.67388e-15
C53 PAD_N BIAS_P_5 7.59414e-18
C54 BIAS_N_4 BIAS_P_5 1.1554e-16
C55 BIAS_N_2 BIAS_P_5 1.21689e-16
C56 BIAS_P_5 VCM 1.49737e-18
C57 BIAS_N_5 BIAS_P_5 1.15901e-17
C58 BIAS_P_4 PAD_P 8.66282e-17
C59 BIAS_P_4 BIAS_P_5 9.61464e-15
C60 BIAS_P_3 BIAS_P_0 1.10867e-16
C61 BIAS_P_1 BIAS_P_0 3.45373e-15
C62 BIAS_N_0 BIAS_P_2 6.29065e-18
C63 BIAS_P_2 PAD_N 2.18523e-17
C64 BIAS_N_0 PAD_N 4.44001e-16
C65 BIAS_N_0 BIAS_N_4 8.66282e-17
C66 BIAS_N_0 BIAS_N_2 1.0764e-16
C67 BIAS_N_3 BIAS_P_6 1.10694e-16
C68 BIAS_P_3 PAD_P 1.10627e-16
C69 BIAS_N_0 VCM 2.12079e-16
C70 BIAS_N_1 BIAS_P_6 1.0963e-16
C71 BIAS_P_3 BIAS_P_5 8.54567e-18
C72 BIAS_N_4 BIAS_N_2 8.75459e-17
C73 BIAS_N_5 BIAS_N_0 7.62796e-18
C74 BIAS_N_4 VCM 9.53179e-17
C75 BIAS_N_3 BIAS_N_1 1.11596e-16
C76 BIAS_P_1 PAD_P 1.06492e-16
C77 BIAS_P_1 BIAS_P_5 7.62796e-18
C78 BIAS_N_2 VCM 9.63247e-17
C79 BIAS_P_4 BIAS_P_2 8.75459e-17
C80 BIAS_N_5 BIAS_N_4 1.01454e-14
C81 BIAS_N_5 BIAS_N_2 7.80014e-18
C82 BIAS_P_4 PAD_N 1.11873e-17
C83 BIAS_N_5 VCM 5.29875e-17
C84 BIAS_P_5 BIAS_N_6 4.34588e-19
C85 BIAS_P_6 BIAS_P_5 5.64434e-16
C86 BIAS_P_3 BIAS_P_2 6.55301e-15
C87 BIAS_N_3 BIAS_P_5 1.26133e-16
C88 BIAS_N_1 BIAS_P_5 1.19902e-16
C89 BIAS_P_3 PAD_N 1.25396e-17
C90 BIAS_P_2 BIAS_P_1 5.0011e-15
C91 BIAS_N_0 BIAS_P_1 5.21301e-17
C92 PAD_N BIAS_P_1 3.08163e-17
C93 BIAS_P_0 PAD_P 1.17935e-15
C94 BIAS_P_0 BIAS_P_5 7.62796e-18
C95 BIAS_P_4 BIAS_P_3 8.08283e-15
C96 BIAS_P_4 BIAS_P_1 8.68004e-17
C97 BIAS_P_6 BIAS_N_0 1.93994e-16
C98 BIAS_N_4 BIAS_N_6 2.15565e-19
C99 BIAS_P_5 PAD_P 7.62796e-18
C100 BIAS_P_6 PAD_N 1.2928e-19
C101 BIAS_N_3 BIAS_N_0 1.10799e-16
C102 BIAS_P_6 BIAS_N_4 8.66282e-17
C103 BIAS_N_1 BIAS_N_0 3.99133e-15
C104 BIAS_P_6 BIAS_N_2 1.08211e-16
C105 VCM BIAS_N_6 1.0668e-15
C106 BIAS_N_3 BIAS_N_4 8.62475e-15
C107 BIAS_N_5 BIAS_N_6 4.99881e-16
C108 BIAS_P_6 VCM 1.0635e-15
C109 BIAS_N_3 BIAS_N_2 7.09482e-15
C110 BIAS_N_1 BIAS_N_4 8.68004e-17
C111 BIAS_N_1 BIAS_N_2 5.54281e-15
C112 BIAS_P_2 BIAS_P_0 1.08869e-16
C113 BIAS_N_5 BIAS_P_6 7.62796e-18
C114 BIAS_N_3 VCM 9.53855e-17
C115 BIAS_N_0 BIAS_P_0 2.09543e-16
.ends pad_reference_clock_flat_physical
