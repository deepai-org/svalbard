.subckt tx_protected_pad PAD_P PAD_N VSS VCM
XPHYSICAL PAD_P PAD_N VSS VCM ESD_RAIL combined_flat
.ends tx_protected_pad
* NGSPICE file created from combined_flat.ext - technology: gf180mcuD

.subckt combined_flat PAD_P PAD_N VSS VCM ESD_RAIL
X0 a_17005_151825# a_29878_151545# ESD_RAIL ppolyf_u r_width=0.8u r_length=63.855u
X1 ESD_RAIL a_20789_137064# a_18245_110628# ESD_RAIL pfet_06v0 ad=1.3p pd=5.52u as=1.3p ps=5.52u w=5u l=0.7u
X2 ESD_RAIL a_18245_110628# VSS VSS nfet_06v0 ad=13p pd=50.52u as=13p ps=50.52u w=50u l=0.7u
X3 ESD_RAIL a_18245_110628# VSS VSS nfet_06v0 ad=13p pd=50.52u as=13p ps=50.52u w=50u l=0.7u
X4 a_20789_137064# a_19813_137064# VSS VSS nfet_06v0 ad=1.3p pd=5.52u as=1.3p ps=5.52u w=5u l=0.7u
X5 VSS a_18245_110628# ESD_RAIL VSS nfet_06v0 ad=13p pd=50.52u as=13p ps=50.52u w=50u l=0.7u
X6 a_17005_152945# a_29878_152665# ESD_RAIL ppolyf_u r_width=0.8u r_length=63.855u
X7 ESD_RAIL a_18245_110628# VSS VSS nfet_06v0 ad=13p pd=50.52u as=13p ps=50.52u w=50u l=0.7u
X8 VSS a_18245_110628# ESD_RAIL VSS nfet_06v0 ad=13p pd=50.52u as=22p ps=0.10088m w=50u l=0.7u
X9 VSS a_18245_110628# ESD_RAIL VSS nfet_06v0 ad=13p pd=50.52u as=13p ps=50.52u w=50u l=0.7u
X10 VSS a_18245_110628# ESD_RAIL VSS nfet_06v0 ad=13p pd=50.52u as=22p ps=0.10088m w=50u l=0.7u
X11 a_18245_110628# a_20789_137064# ESD_RAIL ESD_RAIL pfet_06v0 ad=1.3p pd=5.52u as=1.3p ps=5.52u w=5u l=0.7u
X12 VSS a_18245_110628# ESD_RAIL VSS nfet_06v0 ad=13p pd=50.52u as=13p ps=50.52u w=50u l=0.7u
X13 ESD_RAIL a_18245_110628# VSS VSS nfet_06v0 ad=13p pd=50.52u as=13p ps=50.52u w=50u l=0.7u
X14 ESD_RAIL a_20789_137064# a_18245_110628# ESD_RAIL pfet_06v0 ad=1.3p pd=5.52u as=1.3p ps=5.52u w=5u l=0.7u
X15 ESD_RAIL a_18245_110628# VSS VSS nfet_06v0 ad=13p pd=50.52u as=13p ps=50.52u w=50u l=0.7u
X16 BIAS_N_1 BIAS_N_2 VSS ppolyf_u_1k r_width=1u r_length=12.5u
D0 VSS PAD_P diode_nd2ps_06v0 pj=51.8u area=22.5p
D1 VSS PAD_N diode_nd2ps_06v0 pj=51.8u area=22.5p
D2 VSS PAD_N diode_nd2ps_06v0 pj=51.8u area=22.5p
X17 ESD_RAIL a_20789_137064# a_18245_110628# ESD_RAIL pfet_06v0 ad=2.2p pd=10.88u as=1.3p ps=5.52u w=5u l=0.7u
X18 VSS a_18245_110628# ESD_RAIL VSS nfet_06v0 ad=13p pd=50.52u as=13p ps=50.52u w=50u l=0.7u
X19 a_17005_154065# a_29878_153785# ESD_RAIL ppolyf_u r_width=0.8u r_length=63.855u
X20 BIAS_P_3 BIAS_P_4 VSS ppolyf_u_1k r_width=1u r_length=12.5u
X21 VSS a_18245_110628# ESD_RAIL VSS nfet_06v0 ad=13p pd=50.52u as=13p ps=50.52u w=50u l=0.7u
X22 VSS a_18245_110628# ESD_RAIL VSS nfet_06v0 ad=13p pd=50.52u as=13p ps=50.52u w=50u l=0.7u
D3 VSS ESD_RAIL diode_nd2ps_06v0 pj=82u area=40p
X23 ESD_RAIL a_18245_110628# VSS VSS nfet_06v0 ad=13p pd=50.52u as=13p ps=50.52u w=50u l=0.7u
X24 a_19813_137064# a_17005_151545# ESD_RAIL ESD_RAIL pfet_06v0 ad=1.3p pd=5.52u as=2.2p ps=10.88u w=5u l=0.7u
X25 ESD_RAIL a_17005_151545# a_19813_137064# ESD_RAIL pfet_06v0 ad=1.3p pd=5.52u as=1.3p ps=5.52u w=5u l=0.7u
X26 ESD_RAIL a_18245_110628# VSS VSS nfet_06v0 ad=13p pd=50.52u as=13p ps=50.52u w=50u l=0.7u
X27 ESD_RAIL a_18245_110628# VSS VSS nfet_06v0 ad=22p pd=0.10088m as=13p ps=50.52u w=50u l=0.7u
X28 ESD_RAIL a_18245_110628# VSS VSS nfet_06v0 ad=13p pd=50.52u as=13p ps=50.52u w=50u l=0.7u
X29 VSS a_18245_110628# ESD_RAIL VSS nfet_06v0 ad=13p pd=50.52u as=13p ps=50.52u w=50u l=0.7u
X30 VSS a_18245_110628# ESD_RAIL VSS nfet_06v0 ad=13p pd=50.52u as=13p ps=50.52u w=50u l=0.7u
X31 VSS a_18245_110628# ESD_RAIL VSS nfet_06v0 ad=13p pd=50.52u as=22p ps=0.10088m w=50u l=0.7u
X32 a_18245_110628# a_20789_137064# ESD_RAIL ESD_RAIL pfet_06v0 ad=1.3p pd=5.52u as=1.3p ps=5.52u w=5u l=0.7u
X33 ESD_RAIL a_20789_137064# a_18245_110628# ESD_RAIL pfet_06v0 ad=1.3p pd=5.52u as=1.3p ps=5.52u w=5u l=0.7u
X34 VSS a_18245_110628# ESD_RAIL VSS nfet_06v0 ad=13p pd=50.52u as=13p ps=50.52u w=50u l=0.7u
X35 VSS a_18245_110628# ESD_RAIL VSS nfet_06v0 ad=13p pd=50.52u as=13p ps=50.52u w=50u l=0.7u
X36 a_18245_110628# a_20789_137064# ESD_RAIL ESD_RAIL pfet_06v0 ad=1.3p pd=5.52u as=1.3p ps=5.52u w=5u l=0.7u
X37 ESD_RAIL a_18245_110628# VSS VSS nfet_06v0 ad=13p pd=50.52u as=13p ps=50.52u w=50u l=0.7u
X38 ESD_RAIL a_20789_137064# a_18245_110628# ESD_RAIL pfet_06v0 ad=1.3p pd=5.52u as=1.3p ps=5.52u w=5u l=0.7u
D4 VSS PAD_P diode_nd2ps_06v0 pj=51.8u area=22.5p
X39 ESD_RAIL a_18245_110628# VSS VSS nfet_06v0 ad=13p pd=50.52u as=13p ps=50.52u w=50u l=0.7u
X40 ESD_RAIL a_20789_137064# a_18245_110628# ESD_RAIL pfet_06v0 ad=1.3p pd=5.52u as=1.3p ps=5.52u w=5u l=0.7u
X41 a_18245_110628# a_20789_137064# ESD_RAIL ESD_RAIL pfet_06v0 ad=1.3p pd=5.52u as=1.3p ps=5.52u w=5u l=0.7u
X42 a_18245_110628# a_20789_137064# VSS VSS nfet_06v0 ad=1.3p pd=5.52u as=1.3p ps=5.52u w=5u l=0.7u
X43 VSS a_18245_110628# ESD_RAIL VSS nfet_06v0 ad=13p pd=50.52u as=13p ps=50.52u w=50u l=0.7u
X44 a_18245_110628# a_20789_137064# ESD_RAIL ESD_RAIL pfet_06v0 ad=1.3p pd=5.52u as=1.3p ps=5.52u w=5u l=0.7u
X45 VSS a_18245_110628# ESD_RAIL VSS nfet_06v0 ad=13p pd=50.52u as=13p ps=50.52u w=50u l=0.7u
X46 a_17005_151545# a_29878_151545# ESD_RAIL ppolyf_u r_width=0.8u r_length=63.855u
X47 VSS a_18245_110628# ESD_RAIL VSS nfet_06v0 ad=13p pd=50.52u as=13p ps=50.52u w=50u l=0.7u
X48 VSS a_18245_110628# ESD_RAIL VSS nfet_06v0 ad=13p pd=50.52u as=13p ps=50.52u w=50u l=0.7u
D5 PAD_N ESD_RAIL diode_pd2nw_06v0 pj=51.8u area=22.5p
D6 PAD_P ESD_RAIL diode_pd2nw_06v0 pj=51.8u area=22.5p
D7 PAD_N ESD_RAIL diode_pd2nw_06v0 pj=51.8u area=22.5p
X49 ESD_RAIL a_18245_110628# VSS VSS nfet_06v0 ad=13p pd=50.52u as=13p ps=50.52u w=50u l=0.7u
X50 ESD_RAIL a_18245_110628# VSS VSS nfet_06v0 ad=13p pd=50.52u as=13p ps=50.52u w=50u l=0.7u
X51 a_18245_110628# a_20789_137064# ESD_RAIL ESD_RAIL pfet_06v0 ad=1.3p pd=5.52u as=1.3p ps=5.52u w=5u l=0.7u
X52 a_17005_152385# a_29878_152665# ESD_RAIL ppolyf_u r_width=0.8u r_length=63.855u
X53 a_18245_110628# a_20789_137064# ESD_RAIL ESD_RAIL pfet_06v0 ad=1.3p pd=5.52u as=1.3p ps=5.52u w=5u l=0.7u
X54 VSS a_20789_137064# a_18245_110628# VSS nfet_06v0 ad=2.2p pd=10.88u as=1.3p ps=5.52u w=5u l=0.7u
X55 ESD_RAIL a_20789_137064# a_18245_110628# ESD_RAIL pfet_06v0 ad=1.3p pd=5.52u as=1.3p ps=5.52u w=5u l=0.7u
X56 VSS a_18245_110628# ESD_RAIL VSS nfet_06v0 ad=13p pd=50.52u as=13p ps=50.52u w=50u l=0.7u
X57 BIAS_P_1 BIAS_P_2 VSS ppolyf_u_1k r_width=1u r_length=12.5u
X58 VSS a_18245_110628# ESD_RAIL VSS nfet_06v0 ad=13p pd=50.52u as=13p ps=50.52u w=50u l=0.7u
X59 VSS a_18245_110628# ESD_RAIL VSS nfet_06v0 ad=13p pd=50.52u as=13p ps=50.52u w=50u l=0.7u
X60 BIAS_N_0 BIAS_N_1 VSS ppolyf_u_1k r_width=1u r_length=12.5u
X61 ESD_RAIL a_20789_137064# a_18245_110628# ESD_RAIL pfet_06v0 ad=1.3p pd=5.52u as=1.3p ps=5.52u w=5u l=0.7u
X62 a_18245_110628# a_20789_137064# VSS VSS nfet_06v0 ad=1.3p pd=5.52u as=1.3p ps=5.52u w=5u l=0.7u
X63 a_18245_110628# a_20789_137064# ESD_RAIL ESD_RAIL pfet_06v0 ad=1.3p pd=5.52u as=2.2p ps=10.88u w=5u l=0.7u
X64 a_19813_137064# a_17005_151545# VSS VSS nfet_06v0 ad=2.2p pd=10.88u as=2.2p ps=10.88u w=5u l=0.7u
X65 a_17005_153505# a_29878_153785# ESD_RAIL ppolyf_u r_width=0.8u r_length=63.855u
X66 a_18245_110628# a_20789_137064# ESD_RAIL ESD_RAIL pfet_06v0 ad=1.3p pd=5.52u as=1.3p ps=5.52u w=5u l=0.7u
X67 VSS a_19813_137064# a_20789_137064# VSS nfet_06v0 ad=1.3p pd=5.52u as=1.3p ps=5.52u w=5u l=0.7u
X68 a_18245_110628# a_20789_137064# VSS VSS nfet_06v0 ad=1.3p pd=5.52u as=1.3p ps=5.52u w=5u l=0.7u
X69 ESD_RAIL a_18245_110628# VSS VSS nfet_06v0 ad=13p pd=50.52u as=13p ps=50.52u w=50u l=0.7u
X70 ESD_RAIL a_18245_110628# VSS VSS nfet_06v0 ad=13p pd=50.52u as=13p ps=50.52u w=50u l=0.7u
X71 ESD_RAIL a_18245_110628# VSS VSS nfet_06v0 ad=13p pd=50.52u as=13p ps=50.52u w=50u l=0.7u
X72 VSS a_19813_137064# a_20789_137064# VSS nfet_06v0 ad=1.3p pd=5.52u as=1.3p ps=5.52u w=5u l=0.7u
D8 VSS ESD_RAIL diode_nd2ps_06v0 pj=82u area=40p
X73 VSS a_18245_110628# ESD_RAIL VSS nfet_06v0 ad=13p pd=50.52u as=13p ps=50.52u w=50u l=0.7u
X74 VSS a_18245_110628# ESD_RAIL VSS nfet_06v0 ad=13p pd=50.52u as=13p ps=50.52u w=50u l=0.7u
X75 VSS a_18245_110628# ESD_RAIL VSS nfet_06v0 ad=13p pd=50.52u as=13p ps=50.52u w=50u l=0.7u
X76 BIAS_P_6 VCM VSS ppolyf_u_1k r_width=1u r_length=12.5u
X77 VSS a_18245_110628# ESD_RAIL VSS nfet_06v0 ad=13p pd=50.52u as=13p ps=50.52u w=50u l=0.7u
X78 VSS a_18245_110628# ESD_RAIL VSS nfet_06v0 ad=13p pd=50.52u as=13p ps=50.52u w=50u l=0.7u
X79 VSS a_18245_110628# ESD_RAIL VSS nfet_06v0 ad=13p pd=50.52u as=13p ps=50.52u w=50u l=0.7u
X80 a_17005_153505# a_29878_153225# ESD_RAIL ppolyf_u r_width=0.8u r_length=63.855u
X81 ESD_RAIL a_18245_110628# VSS VSS nfet_06v0 ad=22p pd=0.10088m as=13p ps=50.52u w=50u l=0.7u
D9 PAD_P ESD_RAIL diode_pd2nw_06v0 pj=51.8u area=22.5p
X82 ESD_RAIL a_29878_154345# ESD_RAIL ppolyf_u r_width=0.8u r_length=63.855u
X83 ESD_RAIL a_18245_110628# VSS VSS nfet_06v0 ad=13p pd=50.52u as=13p ps=50.52u w=50u l=0.7u
X84 VSS a_18245_110628# ESD_RAIL VSS nfet_06v0 ad=13p pd=50.52u as=13p ps=50.52u w=50u l=0.7u
X85 VSS a_18245_110628# ESD_RAIL VSS nfet_06v0 ad=13p pd=50.52u as=22p ps=0.10088m w=50u l=0.7u
X86 VSS a_18245_110628# ESD_RAIL VSS nfet_06v0 ad=13p pd=50.52u as=13p ps=50.52u w=50u l=0.7u
X87 a_17005_151545# VSS cap_mim_2f0_m4m5_noshield c_width=31.6u c_length=31.6u
X88 ESD_RAIL a_18245_110628# VSS VSS nfet_06v0 ad=22p pd=0.10088m as=13p ps=50.52u w=50u l=0.7u
X89 ESD_RAIL a_18245_110628# VSS VSS nfet_06v0 ad=13p pd=50.52u as=13p ps=50.52u w=50u l=0.7u
X90 a_20789_137064# a_19813_137064# VSS VSS nfet_06v0 ad=1.3p pd=5.52u as=2.2p ps=10.88u w=5u l=0.7u
X91 ESD_RAIL a_18245_110628# VSS VSS nfet_06v0 ad=13p pd=50.52u as=13p ps=50.52u w=50u l=0.7u
X92 VSS a_18245_110628# ESD_RAIL VSS nfet_06v0 ad=13p pd=50.52u as=13p ps=50.52u w=50u l=0.7u
X93 BIAS_N_4 BIAS_N_5 VSS ppolyf_u_1k r_width=1u r_length=12.5u
D10 VSS PAD_P diode_nd2ps_06v0 pj=51.8u area=22.5p
D11 VSS PAD_N diode_nd2ps_06v0 pj=51.8u area=22.5p
X94 a_18245_110628# a_20789_137064# ESD_RAIL ESD_RAIL pfet_06v0 ad=1.3p pd=5.52u as=1.3p ps=5.52u w=5u l=0.7u
D12 VSS PAD_P diode_nd2ps_06v0 pj=51.8u area=22.5p
X95 VSS a_18245_110628# ESD_RAIL VSS nfet_06v0 ad=13p pd=50.52u as=13p ps=50.52u w=50u l=0.7u
X96 ESD_RAIL a_20789_137064# a_18245_110628# ESD_RAIL pfet_06v0 ad=1.3p pd=5.52u as=1.3p ps=5.52u w=5u l=0.7u
X97 BIAS_P_0 BIAS_P_1 VSS ppolyf_u_1k r_width=1u r_length=12.5u
X98 ESD_RAIL a_18245_110628# VSS VSS nfet_06v0 ad=13p pd=50.52u as=13p ps=50.52u w=50u l=0.7u
X99 ESD_RAIL a_18245_110628# VSS VSS nfet_06v0 ad=13p pd=50.52u as=13p ps=50.52u w=50u l=0.7u
X100 ESD_RAIL a_18245_110628# VSS VSS nfet_06v0 ad=13p pd=50.52u as=13p ps=50.52u w=50u l=0.7u
X101 ESD_RAIL a_18245_110628# VSS VSS nfet_06v0 ad=13p pd=50.52u as=13p ps=50.52u w=50u l=0.7u
X102 BIAS_N_6 VCM VSS ppolyf_u_1k r_width=1u r_length=12.5u
X103 a_17005_152385# a_29878_152105# ESD_RAIL ppolyf_u r_width=0.8u r_length=63.855u
X104 a_19813_137064# a_17005_151545# ESD_RAIL ESD_RAIL pfet_06v0 ad=1.3p pd=5.52u as=1.3p ps=5.52u w=5u l=0.7u
X105 VSS a_18245_110628# ESD_RAIL VSS nfet_06v0 ad=13p pd=50.52u as=13p ps=50.52u w=50u l=0.7u
X106 VSS a_18245_110628# ESD_RAIL VSS nfet_06v0 ad=13p pd=50.52u as=13p ps=50.52u w=50u l=0.7u
X107 VSS a_18245_110628# ESD_RAIL VSS nfet_06v0 ad=13p pd=50.52u as=13p ps=50.52u w=50u l=0.7u
X108 ESD_RAIL a_17005_151545# a_19813_137064# ESD_RAIL pfet_06v0 ad=1.3p pd=5.52u as=1.3p ps=5.52u w=5u l=0.7u
X109 a_20789_137064# a_19813_137064# ESD_RAIL ESD_RAIL pfet_06v0 ad=2.2p pd=10.88u as=1.3p ps=5.52u w=5u l=0.7u
X110 PAD_P BIAS_P_0 VSS ppolyf_u_1k r_width=1u r_length=12.5u
X111 ESD_RAIL a_18245_110628# VSS VSS nfet_06v0 ad=13p pd=50.52u as=13p ps=50.52u w=50u l=0.7u
X112 a_18245_110628# a_20789_137064# ESD_RAIL ESD_RAIL pfet_06v0 ad=1.3p pd=5.52u as=1.3p ps=5.52u w=5u l=0.7u
X113 ESD_RAIL a_18245_110628# VSS VSS nfet_06v0 ad=13p pd=50.52u as=13p ps=50.52u w=50u l=0.7u
X114 BIAS_N_2 BIAS_N_3 VSS ppolyf_u_1k r_width=1u r_length=12.5u
X115 BIAS_P_5 BIAS_P_6 VSS ppolyf_u_1k r_width=1u r_length=12.5u
X116 ESD_RAIL a_18245_110628# VSS VSS nfet_06v0 ad=13p pd=50.52u as=13p ps=50.52u w=50u l=0.7u
X117 a_17005_151825# a_29878_152105# ESD_RAIL ppolyf_u r_width=0.8u r_length=63.855u
X118 ESD_RAIL a_20789_137064# a_18245_110628# ESD_RAIL pfet_06v0 ad=1.3p pd=5.52u as=1.3p ps=5.52u w=5u l=0.7u
X119 ESD_RAIL a_18245_110628# VSS VSS nfet_06v0 ad=13p pd=50.52u as=13p ps=50.52u w=50u l=0.7u
X120 VSS a_18245_110628# ESD_RAIL VSS nfet_06v0 ad=13p pd=50.52u as=13p ps=50.52u w=50u l=0.7u
X121 ESD_RAIL a_19813_137064# a_20789_137064# ESD_RAIL pfet_06v0 ad=1.3p pd=5.52u as=1.3p ps=5.52u w=5u l=0.7u
X122 a_18245_110628# a_20789_137064# ESD_RAIL ESD_RAIL pfet_06v0 ad=1.3p pd=5.52u as=1.3p ps=5.52u w=5u l=0.7u
X123 ESD_RAIL a_20789_137064# a_18245_110628# ESD_RAIL pfet_06v0 ad=1.3p pd=5.52u as=1.3p ps=5.52u w=5u l=0.7u
D13 VSS PAD_N diode_nd2ps_06v0 pj=51.8u area=22.5p
X124 VSS a_18245_110628# ESD_RAIL VSS nfet_06v0 ad=13p pd=50.52u as=13p ps=50.52u w=50u l=0.7u
X125 ESD_RAIL a_18245_110628# VSS VSS nfet_06v0 ad=22p pd=0.10088m as=13p ps=50.52u w=50u l=0.7u
X126 a_17005_152945# a_29878_153225# ESD_RAIL ppolyf_u r_width=0.8u r_length=63.855u
X127 a_20789_137064# a_19813_137064# ESD_RAIL ESD_RAIL pfet_06v0 ad=1.3p pd=5.52u as=1.3p ps=5.52u w=5u l=0.7u
X128 ESD_RAIL a_18245_110628# VSS VSS nfet_06v0 ad=13p pd=50.52u as=13p ps=50.52u w=50u l=0.7u
X129 ESD_RAIL a_18245_110628# VSS VSS nfet_06v0 ad=13p pd=50.52u as=13p ps=50.52u w=50u l=0.7u
X130 VSS a_18245_110628# ESD_RAIL VSS nfet_06v0 ad=13p pd=50.52u as=13p ps=50.52u w=50u l=0.7u
X131 ESD_RAIL a_18245_110628# VSS VSS nfet_06v0 ad=13p pd=50.52u as=13p ps=50.52u w=50u l=0.7u
X132 a_17005_154065# a_29878_154345# ESD_RAIL ppolyf_u r_width=0.8u r_length=63.855u
D14 PAD_P ESD_RAIL diode_pd2nw_06v0 pj=51.8u area=22.5p
X133 ESD_RAIL a_18245_110628# VSS VSS nfet_06v0 ad=13p pd=50.52u as=13p ps=50.52u w=50u l=0.7u
D15 PAD_P ESD_RAIL diode_pd2nw_06v0 pj=51.8u area=22.5p
D16 PAD_N ESD_RAIL diode_pd2nw_06v0 pj=51.8u area=22.5p
X134 VSS ESD_RAIL VSS ppolyf_u_1k_6p0 r_width=1u r_length=9.98874m
X135 ESD_RAIL a_18245_110628# VSS VSS nfet_06v0 ad=13p pd=50.52u as=13p ps=50.52u w=50u l=0.7u
X136 BIAS_P_4 BIAS_P_5 VSS ppolyf_u_1k r_width=1u r_length=12.5u
X137 VSS a_19813_137064# a_20789_137064# VSS nfet_06v0 ad=1.3p pd=5.52u as=1.3p ps=5.52u w=5u l=0.7u
X138 BIAS_N_3 BIAS_N_4 VSS ppolyf_u_1k r_width=1u r_length=12.5u
X139 ESD_RAIL a_18245_110628# VSS VSS nfet_06v0 ad=13p pd=50.52u as=13p ps=50.52u w=50u l=0.7u
X140 VSS a_20789_137064# a_18245_110628# VSS nfet_06v0 ad=1.3p pd=5.52u as=1.3p ps=5.52u w=5u l=0.7u
X141 ESD_RAIL a_20789_137064# a_18245_110628# ESD_RAIL pfet_06v0 ad=1.3p pd=5.52u as=1.3p ps=5.52u w=5u l=0.7u
X142 VSS a_20789_137064# a_18245_110628# VSS nfet_06v0 ad=1.3p pd=5.52u as=1.3p ps=5.52u w=5u l=0.7u
X143 VSS a_18245_110628# ESD_RAIL VSS nfet_06v0 ad=13p pd=50.52u as=13p ps=50.52u w=50u l=0.7u
X144 VSS a_18245_110628# ESD_RAIL VSS nfet_06v0 ad=13p pd=50.52u as=13p ps=50.52u w=50u l=0.7u
X145 a_20789_137064# a_19813_137064# VSS VSS nfet_06v0 ad=1.3p pd=5.52u as=1.3p ps=5.52u w=5u l=0.7u
X146 VSS a_18245_110628# ESD_RAIL VSS nfet_06v0 ad=13p pd=50.52u as=13p ps=50.52u w=50u l=0.7u
X147 BIAS_N_5 BIAS_N_6 VSS ppolyf_u_1k r_width=1u r_length=12.5u
X148 ESD_RAIL a_18245_110628# VSS VSS nfet_06v0 ad=13p pd=50.52u as=13p ps=50.52u w=50u l=0.7u
X149 ESD_RAIL a_18245_110628# VSS VSS nfet_06v0 ad=13p pd=50.52u as=13p ps=50.52u w=50u l=0.7u
X150 ESD_RAIL a_18245_110628# VSS VSS nfet_06v0 ad=13p pd=50.52u as=13p ps=50.52u w=50u l=0.7u
X151 ESD_RAIL a_18245_110628# VSS VSS nfet_06v0 ad=13p pd=50.52u as=13p ps=50.52u w=50u l=0.7u
D17 VSS ESD_RAIL diode_nd2ps_06v0 pj=82u area=40p
X152 ESD_RAIL VSS cap_mim_2f0_m4m5_noshield c_width=31.6u c_length=31.6u
D18 VSS ESD_RAIL diode_nd2ps_06v0 pj=82u area=40p
X153 BIAS_P_2 BIAS_P_3 VSS ppolyf_u_1k r_width=1u r_length=12.5u
X154 PAD_N BIAS_N_0 VSS ppolyf_u_1k r_width=1u r_length=12.5u
D19 PAD_N ESD_RAIL diode_pd2nw_06v0 pj=51.8u area=22.5p
C0 a_29878_152105# ESD_RAIL 0.53942f
C1 BIAS_N_4 BIAS_N_1 0.0868f
C2 BIAS_N_5 BIAS_N_1 0.00763f
C3 BIAS_P_6 BIAS_N_1 0.10963f
C4 BIAS_N_0 BIAS_N_1 3.99133f
C5 a_29878_153785# ESD_RAIL 0.53942f
C6 BIAS_P_0 BIAS_P_2 0.10887f
C7 a_17005_154065# ESD_RAIL 0.57348f
C8 m2_18279_144800# a_17005_152385# 0
C9 BIAS_N_4 BIAS_N_2 0.08755f
C10 BIAS_N_2 BIAS_N_5 0.0078f
C11 PAD_N ESD_RAIL 22.0614f
C12 VCM BIAS_N_3 0.09539f
C13 BIAS_N_2 BIAS_P_6 0.10821f
C14 BIAS_N_2 BIAS_N_0 0.10764f
C15 PAD_N BIAS_P_3 0.01254f
C16 a_29878_153785# a_29878_154345# 0.0346f
C17 a_29878_152105# a_29878_151545# 0.0346f
C18 a_17005_152945# ESD_RAIL 0.53823f
C19 BIAS_P_4 BIAS_P_6 0
C20 m2_18279_144800# a_17005_153505# 0
C21 a_17005_152945# a_17005_151545# 0
C22 PAD_P BIAS_N_0 0.00329f
C23 BIAS_N_4 BIAS_P_5 0.11554f
C24 BIAS_P_5 BIAS_N_5 0.01159f
C25 PAD_N BIAS_P_4 0.01119f
C26 BIAS_P_5 BIAS_N_0 0.09834f
C27 BIAS_P_5 BIAS_P_6 0.56443f
C28 a_29878_153225# a_29878_152665# 0.0346f
C29 BIAS_P_1 BIAS_N_0 0.05213f
C30 BIAS_N_4 BIAS_N_6 0
C31 BIAS_N_6 BIAS_N_5 0.49988f
C32 a_20789_137064# ESD_RAIL 13.9519f
C33 a_17005_154065# m2_18279_144800# 0
C34 PAD_N PAD_P 17.2314f
C35 BIAS_P_2 BIAS_N_0 0.00629f
C36 ESD_RAIL a_17005_151545# 96.5489f
C37 a_17005_151825# ESD_RAIL 0.53823f
C38 PAD_N BIAS_P_5 0.00759f
C39 a_18245_110628# ESD_RAIL 0.24219p
C40 BIAS_N_4 VCM 0.09532f
C41 VCM BIAS_N_5 0.05299f
C42 a_20789_137064# a_17005_151545# 0.02879f
C43 BIAS_P_1 PAD_N 0.03082f
C44 VCM BIAS_P_6 1.0635f
C45 VCM BIAS_N_0 0.21208f
C46 ESD_RAIL a_29878_154345# 0.5677f
C47 a_18245_110628# a_20789_137064# 10.1844f
C48 a_17005_152945# m2_18279_144800# 0
C49 BIAS_N_2 BIAS_N_1 5.54281f
C50 a_29878_151545# ESD_RAIL 0.56772f
C51 a_17005_151825# a_17005_151545# 0.03725f
C52 a_18245_110628# a_17005_151545# 0.0135f
C53 PAD_N BIAS_P_2 0.02185f
C54 BIAS_P_0 BIAS_N_0 0.20954f
C55 BIAS_N_3 BIAS_N_5 0.00855f
C56 a_29878_152105# a_29878_152665# 0.0346f
C57 BIAS_N_4 BIAS_N_3 8.62475f
C58 BIAS_P_6 BIAS_N_3 0.11069f
C59 BIAS_N_0 BIAS_N_3 0.1108f
C60 BIAS_P_3 BIAS_P_4 8.08283f
C61 PAD_P ESD_RAIL 24.1165f
C62 BIAS_P_0 PAD_N 0.15393f
C63 m2_18279_144800# ESD_RAIL 5.47988f
C64 BIAS_P_3 PAD_P 0.11063f
C65 BIAS_P_5 BIAS_N_1 0.1199f
C66 BIAS_P_3 BIAS_P_5 0.00855f
C67 a_29878_153225# a_29878_153785# 0.0346f
C68 m2_18279_144800# a_17005_151545# 0.05457f
C69 BIAS_P_1 BIAS_P_3 0.1116f
C70 a_17005_151825# m2_18279_144800# 0
C71 BIAS_P_5 BIAS_N_2 0.12169f
C72 BIAS_P_3 BIAS_P_2 6.55301f
C73 VCM BIAS_N_1 0.09846f
C74 PAD_P BIAS_P_4 0.08663f
C75 a_17005_152945# a_17005_152385# 0.0346f
C76 BIAS_N_4 BIAS_N_5 10.1454f
C77 BIAS_P_5 BIAS_P_4 9.61464f
C78 BIAS_N_4 BIAS_P_6 0.08663f
C79 BIAS_P_6 BIAS_N_5 0.00763f
C80 BIAS_N_4 BIAS_N_0 0.08663f
C81 BIAS_N_0 BIAS_N_5 0.00763f
C82 a_29878_152665# ESD_RAIL 0.53916f
C83 BIAS_P_6 BIAS_N_0 0.19399f
C84 BIAS_P_1 BIAS_P_4 0.0868f
C85 a_17005_154065# a_17005_153505# 0.0346f
C86 BIAS_P_0 BIAS_P_3 0.11087f
C87 BIAS_N_2 VCM 0.09632f
C88 BIAS_N_3 BIAS_N_1 0.1116f
C89 BIAS_P_5 PAD_P 0.00763f
C90 BIAS_P_4 BIAS_P_2 0.08755f
C91 BIAS_P_1 PAD_P 0.10649f
C92 a_17005_152945# a_17005_153505# 0.0346f
C93 PAD_N BIAS_P_6 0
C94 PAD_N BIAS_N_0 0.444f
C95 BIAS_P_1 BIAS_P_5 0.00763f
C96 BIAS_N_2 BIAS_N_3 7.09482f
C97 a_29878_153225# ESD_RAIL 0.53916f
C98 BIAS_P_5 BIAS_N_6 0
C99 a_17005_152385# ESD_RAIL 0.53823f
C100 PAD_P BIAS_P_2 0.1072f
C101 a_19813_137064# ESD_RAIL 4.89902f
C102 BIAS_P_0 BIAS_P_4 0.08663f
C103 BIAS_P_5 BIAS_P_2 0.0078f
C104 a_19813_137064# a_20789_137064# 2.94235f
C105 BIAS_P_1 BIAS_P_2 5.0011f
C106 a_17005_152385# a_17005_151545# 0
C107 a_17005_151825# a_17005_152385# 0.0346f
C108 BIAS_P_5 VCM 0.0015f
C109 a_19813_137064# a_17005_151545# 2.2693f
C110 a_18245_110628# a_19813_137064# 0.00994f
C111 VCM BIAS_N_6 1.0668f
C112 BIAS_P_0 PAD_P 1.17935f
C113 a_17005_153505# ESD_RAIL 0.53842f
C114 BIAS_P_0 BIAS_P_5 0.00763f
C115 BIAS_P_1 BIAS_P_0 3.45373f
C116 BIAS_P_5 BIAS_N_3 0.12613f
C117 VCM VSS 11.8923f
C118 PAD_P VSS 0.27377p
C119 PAD_N VSS 0.27517p
C120 ESD_RAIL VSS 1674.155664f
C121 m2_18279_144800# VSS 7.46506f $ **FLOATING
C122 BIAS_P_4 VSS 16.8847f
C123 BIAS_P_3 VSS 13.9105f
C124 BIAS_P_2 VSS 11.0489f
C125 BIAS_P_1 VSS 8.17942f
C126 BIAS_P_0 VSS 5.61856f
C127 BIAS_N_4 VSS 17.015f
C128 BIAS_N_3 VSS 14.0185f
C129 BIAS_N_2 VSS 11.1732f
C130 BIAS_N_1 VSS 8.34242f
C131 BIAS_N_0 VSS 6.74563f
C132 BIAS_P_6 VSS 4.19511f
C133 BIAS_P_5 VSS 14.0052f
C134 BIAS_N_6 VSS 4.29492f
C135 BIAS_N_5 VSS 14.0325f
C136 a_18245_110628# VSS 0.24797p
C137 a_20789_137064# VSS 12.0947f
C138 a_19813_137064# VSS 5.60447f
C139 a_17005_151545# VSS 0.10822p
C140 a_29878_151545# VSS 0.07835f
C141 a_17005_151825# VSS 0.07377f
C142 a_29878_152105# VSS 0.07394f
C143 a_17005_152385# VSS 0.07377f
C144 a_29878_152665# VSS 0.07394f
C145 a_17005_152945# VSS 0.07377f
C146 a_29878_153225# VSS 0.07394f
C147 a_17005_153505# VSS 0.07377f
C148 a_29878_153785# VSS 0.07394f
C149 a_17005_154065# VSS 0.07377f
C150 a_29878_154345# VSS 0.07838f
DWELL_ARRAY VSS ESD_RAIL diode_nw2ps_06v0 area=569.4528p pj=470.72u
.ends

.lib /home/ubuntu/svalbard/scratch/transceiver-pad-pdk/ngspice/sm141064.ngspice diode_typical
.lib /home/ubuntu/svalbard/scratch/transceiver-pad-pdk/ngspice/sm141064.ngspice mimcap_typical
