* Independent exporter of physical Magic .ext; no schematic substitutions.
* Extracted capacitance included; distributed wire resistance remains absent.
.subckt tx_steering_buffer_flat_physical VDD VSS IN OUT
X0 VSS STAGE_0 STAGE_1 VSS nfet_03v3 w=4u l=0.28u ad=1.76p as=1.04p pd=8.88u ps=4.52u
X1 STAGE_1 STAGE_0 VSS VSS nfet_03v3 w=4u l=0.28u ad=1.04p as=1.76p pd=4.52u ps=8.88u
X2 VDD STAGE_0 STAGE_1 VDD pfet_03v3 w=4u l=0.28u ad=1.76p as=1.04p pd=8.88u ps=4.52u
X3 STAGE_1 STAGE_0 VDD VDD pfet_03v3 w=4u l=0.28u ad=1.04p as=1.04p pd=4.52u ps=4.52u
X4 VDD STAGE_0 STAGE_1 VDD pfet_03v3 w=4u l=0.28u ad=1.04p as=1.04p pd=4.52u ps=4.52u
X5 STAGE_1 STAGE_0 VDD VDD pfet_03v3 w=4u l=0.28u ad=1.04p as=1.76p pd=4.52u ps=8.88u
X6 VSS STAGE_1 STAGE_2 VSS nfet_03v3 w=4u l=0.28u ad=1.76p as=1.04p pd=8.88u ps=4.52u
X7 STAGE_2 STAGE_1 VSS VSS nfet_03v3 w=4u l=0.28u ad=1.04p as=1.04p pd=4.52u ps=4.52u
X8 VSS STAGE_1 STAGE_2 VSS nfet_03v3 w=4u l=0.28u ad=1.04p as=1.04p pd=4.52u ps=4.52u
X9 STAGE_2 STAGE_1 VSS VSS nfet_03v3 w=4u l=0.28u ad=1.04p as=1.04p pd=4.52u ps=4.52u
X10 VSS STAGE_1 STAGE_2 VSS nfet_03v3 w=4u l=0.28u ad=1.04p as=1.04p pd=4.52u ps=4.52u
X11 STAGE_2 STAGE_1 VSS VSS nfet_03v3 w=4u l=0.28u ad=1.04p as=1.04p pd=4.52u ps=4.52u
X12 VSS STAGE_1 STAGE_2 VSS nfet_03v3 w=4u l=0.28u ad=1.04p as=1.04p pd=4.52u ps=4.52u
X13 STAGE_2 STAGE_1 VSS VSS nfet_03v3 w=4u l=0.28u ad=1.04p as=1.76p pd=4.52u ps=8.88u
X14 VDD STAGE_1 STAGE_2 VDD pfet_03v3 w=4u l=0.28u ad=1.76p as=1.04p pd=8.88u ps=4.52u
X15 STAGE_2 STAGE_1 VDD VDD pfet_03v3 w=4u l=0.28u ad=1.04p as=1.04p pd=4.52u ps=4.52u
X16 VDD STAGE_1 STAGE_2 VDD pfet_03v3 w=4u l=0.28u ad=1.04p as=1.04p pd=4.52u ps=4.52u
X17 STAGE_2 STAGE_1 VDD VDD pfet_03v3 w=4u l=0.28u ad=1.04p as=1.04p pd=4.52u ps=4.52u
X18 VDD STAGE_1 STAGE_2 VDD pfet_03v3 w=4u l=0.28u ad=1.04p as=1.04p pd=4.52u ps=4.52u
X19 STAGE_2 STAGE_1 VDD VDD pfet_03v3 w=4u l=0.28u ad=1.04p as=1.04p pd=4.52u ps=4.52u
X20 VDD STAGE_1 STAGE_2 VDD pfet_03v3 w=4u l=0.28u ad=1.04p as=1.04p pd=4.52u ps=4.52u
X21 STAGE_2 STAGE_1 VDD VDD pfet_03v3 w=4u l=0.28u ad=1.04p as=1.04p pd=4.52u ps=4.52u
X22 VDD STAGE_1 STAGE_2 VDD pfet_03v3 w=4u l=0.28u ad=1.04p as=1.04p pd=4.52u ps=4.52u
X23 STAGE_2 STAGE_1 VDD VDD pfet_03v3 w=4u l=0.28u ad=1.04p as=1.04p pd=4.52u ps=4.52u
X24 VDD STAGE_1 STAGE_2 VDD pfet_03v3 w=4u l=0.28u ad=1.04p as=1.04p pd=4.52u ps=4.52u
X25 STAGE_2 STAGE_1 VDD VDD pfet_03v3 w=4u l=0.28u ad=1.04p as=1.04p pd=4.52u ps=4.52u
X26 VDD STAGE_1 STAGE_2 VDD pfet_03v3 w=4u l=0.28u ad=1.04p as=1.04p pd=4.52u ps=4.52u
X27 STAGE_2 STAGE_1 VDD VDD pfet_03v3 w=4u l=0.28u ad=1.04p as=1.04p pd=4.52u ps=4.52u
X28 VDD STAGE_1 STAGE_2 VDD pfet_03v3 w=4u l=0.28u ad=1.04p as=1.04p pd=4.52u ps=4.52u
X29 STAGE_2 STAGE_1 VDD VDD pfet_03v3 w=4u l=0.28u ad=1.04p as=1.76p pd=4.52u ps=8.88u
X30 VSS STAGE_2 OUT VSS nfet_03v3 w=4u l=0.28u ad=1.76p as=1.04p pd=8.88u ps=4.52u
X31 OUT STAGE_2 VSS VSS nfet_03v3 w=4u l=0.28u ad=1.04p as=1.04p pd=4.52u ps=4.52u
X32 VSS STAGE_2 OUT VSS nfet_03v3 w=4u l=0.28u ad=1.04p as=1.04p pd=4.52u ps=4.52u
X33 OUT STAGE_2 VSS VSS nfet_03v3 w=4u l=0.28u ad=1.04p as=1.04p pd=4.52u ps=4.52u
X34 VSS STAGE_2 OUT VSS nfet_03v3 w=4u l=0.28u ad=1.04p as=1.04p pd=4.52u ps=4.52u
X35 OUT STAGE_2 VSS VSS nfet_03v3 w=4u l=0.28u ad=1.04p as=1.04p pd=4.52u ps=4.52u
X36 VSS STAGE_2 OUT VSS nfet_03v3 w=4u l=0.28u ad=1.04p as=1.04p pd=4.52u ps=4.52u
X37 OUT STAGE_2 VSS VSS nfet_03v3 w=4u l=0.28u ad=1.04p as=1.76p pd=4.52u ps=8.88u
X38 VSS STAGE_2 OUT VSS nfet_03v3 w=4u l=0.28u ad=1.76p as=1.04p pd=8.88u ps=4.52u
X39 OUT STAGE_2 VSS VSS nfet_03v3 w=4u l=0.28u ad=1.04p as=1.04p pd=4.52u ps=4.52u
X40 VSS STAGE_2 OUT VSS nfet_03v3 w=4u l=0.28u ad=1.04p as=1.04p pd=4.52u ps=4.52u
X41 OUT STAGE_2 VSS VSS nfet_03v3 w=4u l=0.28u ad=1.04p as=1.04p pd=4.52u ps=4.52u
X42 VSS STAGE_2 OUT VSS nfet_03v3 w=4u l=0.28u ad=1.04p as=1.04p pd=4.52u ps=4.52u
X43 OUT STAGE_2 VSS VSS nfet_03v3 w=4u l=0.28u ad=1.04p as=1.04p pd=4.52u ps=4.52u
X44 VSS STAGE_2 OUT VSS nfet_03v3 w=4u l=0.28u ad=1.04p as=1.04p pd=4.52u ps=4.52u
X45 OUT STAGE_2 VSS VSS nfet_03v3 w=4u l=0.28u ad=1.04p as=1.76p pd=4.52u ps=8.88u
X46 VSS STAGE_2 OUT VSS nfet_03v3 w=4u l=0.28u ad=1.76p as=1.04p pd=8.88u ps=4.52u
X47 OUT STAGE_2 VSS VSS nfet_03v3 w=4u l=0.28u ad=1.04p as=1.04p pd=4.52u ps=4.52u
X48 VSS STAGE_2 OUT VSS nfet_03v3 w=4u l=0.28u ad=1.04p as=1.04p pd=4.52u ps=4.52u
X49 OUT STAGE_2 VSS VSS nfet_03v3 w=4u l=0.28u ad=1.04p as=1.04p pd=4.52u ps=4.52u
X50 VSS STAGE_2 OUT VSS nfet_03v3 w=4u l=0.28u ad=1.04p as=1.04p pd=4.52u ps=4.52u
X51 OUT STAGE_2 VSS VSS nfet_03v3 w=4u l=0.28u ad=1.04p as=1.04p pd=4.52u ps=4.52u
X52 VSS STAGE_2 OUT VSS nfet_03v3 w=4u l=0.28u ad=1.04p as=1.04p pd=4.52u ps=4.52u
X53 OUT STAGE_2 VSS VSS nfet_03v3 w=4u l=0.28u ad=1.04p as=1.76p pd=4.52u ps=8.88u
X54 VSS STAGE_2 OUT VSS nfet_03v3 w=4u l=0.28u ad=1.76p as=1.04p pd=8.88u ps=4.52u
X55 OUT STAGE_2 VSS VSS nfet_03v3 w=4u l=0.28u ad=1.04p as=1.04p pd=4.52u ps=4.52u
X56 VSS STAGE_2 OUT VSS nfet_03v3 w=4u l=0.28u ad=1.04p as=1.04p pd=4.52u ps=4.52u
X57 OUT STAGE_2 VSS VSS nfet_03v3 w=4u l=0.28u ad=1.04p as=1.04p pd=4.52u ps=4.52u
X58 VSS STAGE_2 OUT VSS nfet_03v3 w=4u l=0.28u ad=1.04p as=1.04p pd=4.52u ps=4.52u
X59 OUT STAGE_2 VSS VSS nfet_03v3 w=4u l=0.28u ad=1.04p as=1.04p pd=4.52u ps=4.52u
X60 VSS STAGE_2 OUT VSS nfet_03v3 w=4u l=0.28u ad=1.04p as=1.04p pd=4.52u ps=4.52u
X61 OUT STAGE_2 VSS VSS nfet_03v3 w=4u l=0.28u ad=1.04p as=1.76p pd=4.52u ps=8.88u
X62 VDD STAGE_2 OUT VDD pfet_03v3 w=4u l=0.28u ad=1.76p as=1.04p pd=8.88u ps=4.52u
X63 OUT STAGE_2 VDD VDD pfet_03v3 w=4u l=0.28u ad=1.04p as=1.04p pd=4.52u ps=4.52u
X64 VDD STAGE_2 OUT VDD pfet_03v3 w=4u l=0.28u ad=1.04p as=1.04p pd=4.52u ps=4.52u
X65 OUT STAGE_2 VDD VDD pfet_03v3 w=4u l=0.28u ad=1.04p as=1.04p pd=4.52u ps=4.52u
X66 VDD STAGE_2 OUT VDD pfet_03v3 w=4u l=0.28u ad=1.04p as=1.04p pd=4.52u ps=4.52u
X67 OUT STAGE_2 VDD VDD pfet_03v3 w=4u l=0.28u ad=1.04p as=1.04p pd=4.52u ps=4.52u
X68 VDD STAGE_2 OUT VDD pfet_03v3 w=4u l=0.28u ad=1.04p as=1.04p pd=4.52u ps=4.52u
X69 OUT STAGE_2 VDD VDD pfet_03v3 w=4u l=0.28u ad=1.04p as=1.04p pd=4.52u ps=4.52u
X70 VDD STAGE_2 OUT VDD pfet_03v3 w=4u l=0.28u ad=1.04p as=1.04p pd=4.52u ps=4.52u
X71 OUT STAGE_2 VDD VDD pfet_03v3 w=4u l=0.28u ad=1.04p as=1.04p pd=4.52u ps=4.52u
X72 VDD STAGE_2 OUT VDD pfet_03v3 w=4u l=0.28u ad=1.04p as=1.04p pd=4.52u ps=4.52u
X73 OUT STAGE_2 VDD VDD pfet_03v3 w=4u l=0.28u ad=1.04p as=1.04p pd=4.52u ps=4.52u
X74 VDD STAGE_2 OUT VDD pfet_03v3 w=4u l=0.28u ad=1.04p as=1.04p pd=4.52u ps=4.52u
X75 OUT STAGE_2 VDD VDD pfet_03v3 w=4u l=0.28u ad=1.04p as=1.04p pd=4.52u ps=4.52u
X76 VDD STAGE_2 OUT VDD pfet_03v3 w=4u l=0.28u ad=1.04p as=1.04p pd=4.52u ps=4.52u
X77 OUT STAGE_2 VDD VDD pfet_03v3 w=4u l=0.28u ad=1.04p as=1.76p pd=4.52u ps=8.88u
X78 VDD STAGE_2 OUT VDD pfet_03v3 w=4u l=0.28u ad=1.76p as=1.04p pd=8.88u ps=4.52u
X79 OUT STAGE_2 VDD VDD pfet_03v3 w=4u l=0.28u ad=1.04p as=1.04p pd=4.52u ps=4.52u
X80 VDD STAGE_2 OUT VDD pfet_03v3 w=4u l=0.28u ad=1.04p as=1.04p pd=4.52u ps=4.52u
X81 OUT STAGE_2 VDD VDD pfet_03v3 w=4u l=0.28u ad=1.04p as=1.04p pd=4.52u ps=4.52u
X82 VDD STAGE_2 OUT VDD pfet_03v3 w=4u l=0.28u ad=1.04p as=1.04p pd=4.52u ps=4.52u
X83 OUT STAGE_2 VDD VDD pfet_03v3 w=4u l=0.28u ad=1.04p as=1.04p pd=4.52u ps=4.52u
X84 VDD STAGE_2 OUT VDD pfet_03v3 w=4u l=0.28u ad=1.04p as=1.04p pd=4.52u ps=4.52u
X85 OUT STAGE_2 VDD VDD pfet_03v3 w=4u l=0.28u ad=1.04p as=1.04p pd=4.52u ps=4.52u
X86 VDD STAGE_2 OUT VDD pfet_03v3 w=4u l=0.28u ad=1.04p as=1.04p pd=4.52u ps=4.52u
X87 OUT STAGE_2 VDD VDD pfet_03v3 w=4u l=0.28u ad=1.04p as=1.04p pd=4.52u ps=4.52u
X88 VDD STAGE_2 OUT VDD pfet_03v3 w=4u l=0.28u ad=1.04p as=1.04p pd=4.52u ps=4.52u
X89 OUT STAGE_2 VDD VDD pfet_03v3 w=4u l=0.28u ad=1.04p as=1.04p pd=4.52u ps=4.52u
X90 VDD STAGE_2 OUT VDD pfet_03v3 w=4u l=0.28u ad=1.04p as=1.04p pd=4.52u ps=4.52u
X91 OUT STAGE_2 VDD VDD pfet_03v3 w=4u l=0.28u ad=1.04p as=1.04p pd=4.52u ps=4.52u
X92 VDD STAGE_2 OUT VDD pfet_03v3 w=4u l=0.28u ad=1.04p as=1.04p pd=4.52u ps=4.52u
X93 OUT STAGE_2 VDD VDD pfet_03v3 w=4u l=0.28u ad=1.04p as=1.76p pd=4.52u ps=8.88u
X94 VDD STAGE_2 OUT VDD pfet_03v3 w=4u l=0.28u ad=1.76p as=1.04p pd=8.88u ps=4.52u
X95 OUT STAGE_2 VDD VDD pfet_03v3 w=4u l=0.28u ad=1.04p as=1.04p pd=4.52u ps=4.52u
X96 VDD STAGE_2 OUT VDD pfet_03v3 w=4u l=0.28u ad=1.04p as=1.04p pd=4.52u ps=4.52u
X97 OUT STAGE_2 VDD VDD pfet_03v3 w=4u l=0.28u ad=1.04p as=1.04p pd=4.52u ps=4.52u
X98 VDD STAGE_2 OUT VDD pfet_03v3 w=4u l=0.28u ad=1.04p as=1.04p pd=4.52u ps=4.52u
X99 OUT STAGE_2 VDD VDD pfet_03v3 w=4u l=0.28u ad=1.04p as=1.04p pd=4.52u ps=4.52u
X100 VDD STAGE_2 OUT VDD pfet_03v3 w=4u l=0.28u ad=1.04p as=1.04p pd=4.52u ps=4.52u
X101 OUT STAGE_2 VDD VDD pfet_03v3 w=4u l=0.28u ad=1.04p as=1.04p pd=4.52u ps=4.52u
X102 VDD STAGE_2 OUT VDD pfet_03v3 w=4u l=0.28u ad=1.04p as=1.04p pd=4.52u ps=4.52u
X103 OUT STAGE_2 VDD VDD pfet_03v3 w=4u l=0.28u ad=1.04p as=1.04p pd=4.52u ps=4.52u
X104 VDD STAGE_2 OUT VDD pfet_03v3 w=4u l=0.28u ad=1.04p as=1.04p pd=4.52u ps=4.52u
X105 OUT STAGE_2 VDD VDD pfet_03v3 w=4u l=0.28u ad=1.04p as=1.04p pd=4.52u ps=4.52u
X106 VDD STAGE_2 OUT VDD pfet_03v3 w=4u l=0.28u ad=1.04p as=1.04p pd=4.52u ps=4.52u
X107 OUT STAGE_2 VDD VDD pfet_03v3 w=4u l=0.28u ad=1.04p as=1.04p pd=4.52u ps=4.52u
X108 VDD STAGE_2 OUT VDD pfet_03v3 w=4u l=0.28u ad=1.04p as=1.04p pd=4.52u ps=4.52u
X109 OUT STAGE_2 VDD VDD pfet_03v3 w=4u l=0.28u ad=1.04p as=1.76p pd=4.52u ps=8.88u
X110 VDD STAGE_2 OUT VDD pfet_03v3 w=4u l=0.28u ad=1.76p as=1.04p pd=8.88u ps=4.52u
X111 OUT STAGE_2 VDD VDD pfet_03v3 w=4u l=0.28u ad=1.04p as=1.04p pd=4.52u ps=4.52u
X112 VDD STAGE_2 OUT VDD pfet_03v3 w=4u l=0.28u ad=1.04p as=1.04p pd=4.52u ps=4.52u
X113 OUT STAGE_2 VDD VDD pfet_03v3 w=4u l=0.28u ad=1.04p as=1.04p pd=4.52u ps=4.52u
X114 VDD STAGE_2 OUT VDD pfet_03v3 w=4u l=0.28u ad=1.04p as=1.04p pd=4.52u ps=4.52u
X115 OUT STAGE_2 VDD VDD pfet_03v3 w=4u l=0.28u ad=1.04p as=1.04p pd=4.52u ps=4.52u
X116 VDD STAGE_2 OUT VDD pfet_03v3 w=4u l=0.28u ad=1.04p as=1.04p pd=4.52u ps=4.52u
X117 OUT STAGE_2 VDD VDD pfet_03v3 w=4u l=0.28u ad=1.04p as=1.04p pd=4.52u ps=4.52u
X118 VDD STAGE_2 OUT VDD pfet_03v3 w=4u l=0.28u ad=1.04p as=1.04p pd=4.52u ps=4.52u
X119 OUT STAGE_2 VDD VDD pfet_03v3 w=4u l=0.28u ad=1.04p as=1.04p pd=4.52u ps=4.52u
X120 VDD STAGE_2 OUT VDD pfet_03v3 w=4u l=0.28u ad=1.04p as=1.04p pd=4.52u ps=4.52u
X121 OUT STAGE_2 VDD VDD pfet_03v3 w=4u l=0.28u ad=1.04p as=1.04p pd=4.52u ps=4.52u
X122 VDD STAGE_2 OUT VDD pfet_03v3 w=4u l=0.28u ad=1.04p as=1.04p pd=4.52u ps=4.52u
X123 OUT STAGE_2 VDD VDD pfet_03v3 w=4u l=0.28u ad=1.04p as=1.04p pd=4.52u ps=4.52u
X124 VDD STAGE_2 OUT VDD pfet_03v3 w=4u l=0.28u ad=1.04p as=1.04p pd=4.52u ps=4.52u
X125 OUT STAGE_2 VDD VDD pfet_03v3 w=4u l=0.28u ad=1.04p as=1.76p pd=4.52u ps=8.88u
X126 STAGE_0 IN VDD VDD pfet_03v3 w=4u l=0.28u ad=1.76p as=1.76p pd=8.88u ps=8.88u
X127 STAGE_0 IN VSS VSS nfet_03v3 w=2u l=0.28u ad=0.88p as=0.88p pd=4.88u ps=4.88u
C0 STAGE_1 VSS 2.26902e-14
C1 OUT VSS 1.08046e-13
C2 STAGE_2 VSS 4.99759e-14
C3 STAGE_0 VSS 1.11277e-14
C4 IN VSS 2.23659e-14
C5 VDD VSS 1.28662e-13
C6 VDD STAGE_0 5.01709e-15
C7 STAGE_1 IN 3.21373e-16
C8 OUT STAGE_0 1.28385e-15
C9 STAGE_1 STAGE_0 1.12273e-15
C10 STAGE_2 IN 5.65125e-16
C11 STAGE_2 STAGE_0 7.98565e-16
C12 VDD OUT 8.79729e-14
C13 STAGE_0 IN 1.94235e-14
C14 VDD STAGE_1 1.99856e-14
C15 OUT STAGE_1 3.85793e-15
C16 VDD STAGE_2 6.95667e-14
C17 OUT STAGE_2 2.0365e-14
C18 STAGE_1 STAGE_2 4.32515e-15
C19 VDD IN 3.30633e-15
C20 OUT IN 9.65109e-16
.ends tx_steering_buffer_flat_physical
