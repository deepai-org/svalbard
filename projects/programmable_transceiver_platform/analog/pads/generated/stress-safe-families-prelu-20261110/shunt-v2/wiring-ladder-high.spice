.subckt rail_shunt_flat RAIL VSS
XM0_0 DI0_0 DI0_0 SI0_0 VSS nfet_06v0 w=50u l=0.7u nf=1 m=10 ad=22p as=22p pd=100.88u ps=100.88u
RVD0_0 DI0_0 D0_0 0.1
RVS0_0 SI0_0 S0_0 0.1
XM0_1 DI0_1 DI0_1 SI0_1 VSS nfet_06v0 w=50u l=0.7u nf=1 m=10 ad=22p as=22p pd=100.88u ps=100.88u
RVD0_1 DI0_1 D0_1 0.1
RVS0_1 SI0_1 S0_1 0.1
RD0_1 D0_0 D0_1 0.0296214
RS0_1 S0_0 S0_1 0.0296214
XM0_2 DI0_2 DI0_2 SI0_2 VSS nfet_06v0 w=50u l=0.7u nf=1 m=10 ad=22p as=22p pd=100.88u ps=100.88u
RVD0_2 DI0_2 D0_2 0.1
RVS0_2 SI0_2 S0_2 0.1
RD0_2 D0_1 D0_2 0.0296214
RS0_2 S0_1 S0_2 0.0296214
XM0_3 DI0_3 DI0_3 SI0_3 VSS nfet_06v0 w=50u l=0.7u nf=1 m=10 ad=22p as=22p pd=100.88u ps=100.88u
RVD0_3 DI0_3 D0_3 0.1
RVS0_3 SI0_3 S0_3 0.1
RD0_3 D0_2 D0_3 0.0296214
RS0_3 S0_2 S0_3 0.0296214
XM0_4 DI0_4 DI0_4 SI0_4 VSS nfet_06v0 w=50u l=0.7u nf=1 m=10 ad=22p as=22p pd=100.88u ps=100.88u
RVD0_4 DI0_4 D0_4 0.1
RVS0_4 SI0_4 S0_4 0.1
RD0_4 D0_3 D0_4 0.0296214
RS0_4 S0_3 S0_4 0.0296214
XM0_5 DI0_5 DI0_5 SI0_5 VSS nfet_06v0 w=50u l=0.7u nf=1 m=10 ad=22p as=22p pd=100.88u ps=100.88u
RVD0_5 DI0_5 D0_5 0.1
RVS0_5 SI0_5 S0_5 0.1
RD0_5 D0_4 D0_5 0.0296214
RS0_5 S0_4 S0_5 0.0296214
XM0_6 DI0_6 DI0_6 SI0_6 VSS nfet_06v0 w=50u l=0.7u nf=1 m=10 ad=22p as=22p pd=100.88u ps=100.88u
RVD0_6 DI0_6 D0_6 0.1
RVS0_6 SI0_6 S0_6 0.1
RD0_6 D0_5 D0_6 0.0296214
RS0_6 S0_5 S0_6 0.0296214
XM0_7 DI0_7 DI0_7 SI0_7 VSS nfet_06v0 w=50u l=0.7u nf=1 m=10 ad=22p as=22p pd=100.88u ps=100.88u
RVD0_7 DI0_7 D0_7 0.1
RVS0_7 SI0_7 S0_7 0.1
RD0_7 D0_6 D0_7 0.0296214
RS0_7 S0_6 S0_7 0.0296214
XM0_8 DI0_8 DI0_8 SI0_8 VSS nfet_06v0 w=50u l=0.7u nf=1 m=10 ad=22p as=22p pd=100.88u ps=100.88u
RVD0_8 DI0_8 D0_8 0.1
RVS0_8 SI0_8 S0_8 0.1
RD0_8 D0_7 D0_8 0.0296214
RS0_8 S0_7 S0_8 0.0296214
XM0_9 DI0_9 DI0_9 SI0_9 VSS nfet_06v0 w=50u l=0.7u nf=1 m=10 ad=22p as=22p pd=100.88u ps=100.88u
RVD0_9 DI0_9 D0_9 0.1
RVS0_9 SI0_9 S0_9 0.1
RD0_9 D0_8 D0_9 0.0296214
RS0_9 S0_8 S0_9 0.0296214
XM0_10 DI0_10 DI0_10 SI0_10 VSS nfet_06v0 w=50u l=0.7u nf=1 m=10 ad=22p as=22p pd=100.88u ps=100.88u
RVD0_10 DI0_10 D0_10 0.1
RVS0_10 SI0_10 S0_10 0.1
RD0_10 D0_9 D0_10 0.0296214
RS0_10 S0_9 S0_10 0.0296214
XM0_11 DI0_11 DI0_11 SI0_11 VSS nfet_06v0 w=50u l=0.7u nf=1 m=10 ad=22p as=22p pd=100.88u ps=100.88u
RVD0_11 DI0_11 D0_11 0.1
RVS0_11 SI0_11 S0_11 0.1
RD0_11 D0_10 D0_11 0.0296214
RS0_11 S0_10 S0_11 0.0296214
XM0_12 DI0_12 DI0_12 SI0_12 VSS nfet_06v0 w=50u l=0.7u nf=1 m=10 ad=22p as=22p pd=100.88u ps=100.88u
RVD0_12 DI0_12 D0_12 0.1
RVS0_12 SI0_12 S0_12 0.1
RD0_12 D0_11 D0_12 0.0296214
RS0_12 S0_11 S0_12 0.0296214
XM0_13 DI0_13 DI0_13 SI0_13 VSS nfet_06v0 w=50u l=0.7u nf=1 m=10 ad=22p as=22p pd=100.88u ps=100.88u
RVD0_13 DI0_13 D0_13 0.1
RVS0_13 SI0_13 S0_13 0.1
RD0_13 D0_12 D0_13 0.0296214
RS0_13 S0_12 S0_13 0.0296214
XM0_14 DI0_14 DI0_14 SI0_14 VSS nfet_06v0 w=50u l=0.7u nf=1 m=10 ad=22p as=22p pd=100.88u ps=100.88u
RVD0_14 DI0_14 D0_14 0.1
RVS0_14 SI0_14 S0_14 0.1
RD0_14 D0_13 D0_14 0.0296214
RS0_14 S0_13 S0_14 0.0296214
XM0_15 DI0_15 DI0_15 SI0_15 VSS nfet_06v0 w=50u l=0.7u nf=1 m=10 ad=22p as=22p pd=100.88u ps=100.88u
RVD0_15 DI0_15 D0_15 0.1
RVS0_15 SI0_15 S0_15 0.1
RD0_15 D0_14 D0_15 0.0296214
RS0_15 S0_14 S0_15 0.0296214
XM0_16 DI0_16 DI0_16 SI0_16 VSS nfet_06v0 w=50u l=0.7u nf=1 m=10 ad=22p as=22p pd=100.88u ps=100.88u
RVD0_16 DI0_16 D0_16 0.1
RVS0_16 SI0_16 S0_16 0.1
RD0_16 D0_15 D0_16 0.0296214
RS0_16 S0_15 S0_16 0.0296214
XM0_17 DI0_17 DI0_17 SI0_17 VSS nfet_06v0 w=50u l=0.7u nf=1 m=10 ad=22p as=22p pd=100.88u ps=100.88u
RVD0_17 DI0_17 D0_17 0.1
RVS0_17 SI0_17 S0_17 0.1
RD0_17 D0_16 D0_17 0.0296214
RS0_17 S0_16 S0_17 0.0296214
XM0_18 DI0_18 DI0_18 SI0_18 VSS nfet_06v0 w=50u l=0.7u nf=1 m=10 ad=22p as=22p pd=100.88u ps=100.88u
RVD0_18 DI0_18 D0_18 0.1
RVS0_18 SI0_18 S0_18 0.1
RD0_18 D0_17 D0_18 0.0296214
RS0_18 S0_17 S0_18 0.0296214
XM0_19 DI0_19 DI0_19 SI0_19 VSS nfet_06v0 w=50u l=0.7u nf=1 m=10 ad=22p as=22p pd=100.88u ps=100.88u
RVD0_19 DI0_19 D0_19 0.1
RVS0_19 SI0_19 S0_19 0.1
RD0_19 D0_18 D0_19 0.0296214
RS0_19 S0_18 S0_19 0.0296214
XM0_20 DI0_20 DI0_20 SI0_20 VSS nfet_06v0 w=50u l=0.7u nf=1 m=10 ad=22p as=22p pd=100.88u ps=100.88u
RVD0_20 DI0_20 D0_20 0.1
RVS0_20 SI0_20 S0_20 0.1
RD0_20 D0_19 D0_20 0.0296214
RS0_20 S0_19 S0_20 0.0296214
XM0_21 DI0_21 DI0_21 SI0_21 VSS nfet_06v0 w=50u l=0.7u nf=1 m=10 ad=22p as=22p pd=100.88u ps=100.88u
RVD0_21 DI0_21 D0_21 0.1
RVS0_21 SI0_21 S0_21 0.1
RD0_21 D0_20 D0_21 0.0296214
RS0_21 S0_20 S0_21 0.0296214
XM0_22 DI0_22 DI0_22 SI0_22 VSS nfet_06v0 w=50u l=0.7u nf=1 m=10 ad=22p as=22p pd=100.88u ps=100.88u
RVD0_22 DI0_22 D0_22 0.1
RVS0_22 SI0_22 S0_22 0.1
RD0_22 D0_21 D0_22 0.0296214
RS0_22 S0_21 S0_22 0.0296214
XM0_23 DI0_23 DI0_23 SI0_23 VSS nfet_06v0 w=50u l=0.7u nf=1 m=10 ad=22p as=22p pd=100.88u ps=100.88u
RVD0_23 DI0_23 D0_23 0.1
RVS0_23 SI0_23 S0_23 0.1
RD0_23 D0_22 D0_23 0.0296214
RS0_23 S0_22 S0_23 0.0296214
XM1_0 DI1_0 DI1_0 SI1_0 VSS nfet_06v0 w=50u l=0.7u nf=1 m=10 ad=22p as=22p pd=100.88u ps=100.88u
RVD1_0 DI1_0 D1_0 0.1
RVS1_0 SI1_0 S1_0 0.1
RJ1_0 S0_0 D1_0 0.495234
XM1_1 DI1_1 DI1_1 SI1_1 VSS nfet_06v0 w=50u l=0.7u nf=1 m=10 ad=22p as=22p pd=100.88u ps=100.88u
RVD1_1 DI1_1 D1_1 0.1
RVS1_1 SI1_1 S1_1 0.1
RD1_1 D1_0 D1_1 0.0296214
RS1_1 S1_0 S1_1 0.0296214
RJ1_1 S0_1 D1_1 0.495234
XM1_2 DI1_2 DI1_2 SI1_2 VSS nfet_06v0 w=50u l=0.7u nf=1 m=10 ad=22p as=22p pd=100.88u ps=100.88u
RVD1_2 DI1_2 D1_2 0.1
RVS1_2 SI1_2 S1_2 0.1
RD1_2 D1_1 D1_2 0.0296214
RS1_2 S1_1 S1_2 0.0296214
RJ1_2 S0_2 D1_2 0.495234
XM1_3 DI1_3 DI1_3 SI1_3 VSS nfet_06v0 w=50u l=0.7u nf=1 m=10 ad=22p as=22p pd=100.88u ps=100.88u
RVD1_3 DI1_3 D1_3 0.1
RVS1_3 SI1_3 S1_3 0.1
RD1_3 D1_2 D1_3 0.0296214
RS1_3 S1_2 S1_3 0.0296214
RJ1_3 S0_3 D1_3 0.495234
XM1_4 DI1_4 DI1_4 SI1_4 VSS nfet_06v0 w=50u l=0.7u nf=1 m=10 ad=22p as=22p pd=100.88u ps=100.88u
RVD1_4 DI1_4 D1_4 0.1
RVS1_4 SI1_4 S1_4 0.1
RD1_4 D1_3 D1_4 0.0296214
RS1_4 S1_3 S1_4 0.0296214
RJ1_4 S0_4 D1_4 0.495234
XM1_5 DI1_5 DI1_5 SI1_5 VSS nfet_06v0 w=50u l=0.7u nf=1 m=10 ad=22p as=22p pd=100.88u ps=100.88u
RVD1_5 DI1_5 D1_5 0.1
RVS1_5 SI1_5 S1_5 0.1
RD1_5 D1_4 D1_5 0.0296214
RS1_5 S1_4 S1_5 0.0296214
RJ1_5 S0_5 D1_5 0.495234
XM1_6 DI1_6 DI1_6 SI1_6 VSS nfet_06v0 w=50u l=0.7u nf=1 m=10 ad=22p as=22p pd=100.88u ps=100.88u
RVD1_6 DI1_6 D1_6 0.1
RVS1_6 SI1_6 S1_6 0.1
RD1_6 D1_5 D1_6 0.0296214
RS1_6 S1_5 S1_6 0.0296214
RJ1_6 S0_6 D1_6 0.495234
XM1_7 DI1_7 DI1_7 SI1_7 VSS nfet_06v0 w=50u l=0.7u nf=1 m=10 ad=22p as=22p pd=100.88u ps=100.88u
RVD1_7 DI1_7 D1_7 0.1
RVS1_7 SI1_7 S1_7 0.1
RD1_7 D1_6 D1_7 0.0296214
RS1_7 S1_6 S1_7 0.0296214
RJ1_7 S0_7 D1_7 0.495234
XM1_8 DI1_8 DI1_8 SI1_8 VSS nfet_06v0 w=50u l=0.7u nf=1 m=10 ad=22p as=22p pd=100.88u ps=100.88u
RVD1_8 DI1_8 D1_8 0.1
RVS1_8 SI1_8 S1_8 0.1
RD1_8 D1_7 D1_8 0.0296214
RS1_8 S1_7 S1_8 0.0296214
RJ1_8 S0_8 D1_8 0.495234
XM1_9 DI1_9 DI1_9 SI1_9 VSS nfet_06v0 w=50u l=0.7u nf=1 m=10 ad=22p as=22p pd=100.88u ps=100.88u
RVD1_9 DI1_9 D1_9 0.1
RVS1_9 SI1_9 S1_9 0.1
RD1_9 D1_8 D1_9 0.0296214
RS1_9 S1_8 S1_9 0.0296214
RJ1_9 S0_9 D1_9 0.495234
XM1_10 DI1_10 DI1_10 SI1_10 VSS nfet_06v0 w=50u l=0.7u nf=1 m=10 ad=22p as=22p pd=100.88u ps=100.88u
RVD1_10 DI1_10 D1_10 0.1
RVS1_10 SI1_10 S1_10 0.1
RD1_10 D1_9 D1_10 0.0296214
RS1_10 S1_9 S1_10 0.0296214
RJ1_10 S0_10 D1_10 0.495234
XM1_11 DI1_11 DI1_11 SI1_11 VSS nfet_06v0 w=50u l=0.7u nf=1 m=10 ad=22p as=22p pd=100.88u ps=100.88u
RVD1_11 DI1_11 D1_11 0.1
RVS1_11 SI1_11 S1_11 0.1
RD1_11 D1_10 D1_11 0.0296214
RS1_11 S1_10 S1_11 0.0296214
RJ1_11 S0_11 D1_11 0.495234
XM1_12 DI1_12 DI1_12 SI1_12 VSS nfet_06v0 w=50u l=0.7u nf=1 m=10 ad=22p as=22p pd=100.88u ps=100.88u
RVD1_12 DI1_12 D1_12 0.1
RVS1_12 SI1_12 S1_12 0.1
RD1_12 D1_11 D1_12 0.0296214
RS1_12 S1_11 S1_12 0.0296214
RJ1_12 S0_12 D1_12 0.495234
XM1_13 DI1_13 DI1_13 SI1_13 VSS nfet_06v0 w=50u l=0.7u nf=1 m=10 ad=22p as=22p pd=100.88u ps=100.88u
RVD1_13 DI1_13 D1_13 0.1
RVS1_13 SI1_13 S1_13 0.1
RD1_13 D1_12 D1_13 0.0296214
RS1_13 S1_12 S1_13 0.0296214
RJ1_13 S0_13 D1_13 0.495234
XM1_14 DI1_14 DI1_14 SI1_14 VSS nfet_06v0 w=50u l=0.7u nf=1 m=10 ad=22p as=22p pd=100.88u ps=100.88u
RVD1_14 DI1_14 D1_14 0.1
RVS1_14 SI1_14 S1_14 0.1
RD1_14 D1_13 D1_14 0.0296214
RS1_14 S1_13 S1_14 0.0296214
RJ1_14 S0_14 D1_14 0.495234
XM1_15 DI1_15 DI1_15 SI1_15 VSS nfet_06v0 w=50u l=0.7u nf=1 m=10 ad=22p as=22p pd=100.88u ps=100.88u
RVD1_15 DI1_15 D1_15 0.1
RVS1_15 SI1_15 S1_15 0.1
RD1_15 D1_14 D1_15 0.0296214
RS1_15 S1_14 S1_15 0.0296214
RJ1_15 S0_15 D1_15 0.495234
XM1_16 DI1_16 DI1_16 SI1_16 VSS nfet_06v0 w=50u l=0.7u nf=1 m=10 ad=22p as=22p pd=100.88u ps=100.88u
RVD1_16 DI1_16 D1_16 0.1
RVS1_16 SI1_16 S1_16 0.1
RD1_16 D1_15 D1_16 0.0296214
RS1_16 S1_15 S1_16 0.0296214
RJ1_16 S0_16 D1_16 0.495234
XM1_17 DI1_17 DI1_17 SI1_17 VSS nfet_06v0 w=50u l=0.7u nf=1 m=10 ad=22p as=22p pd=100.88u ps=100.88u
RVD1_17 DI1_17 D1_17 0.1
RVS1_17 SI1_17 S1_17 0.1
RD1_17 D1_16 D1_17 0.0296214
RS1_17 S1_16 S1_17 0.0296214
RJ1_17 S0_17 D1_17 0.495234
XM1_18 DI1_18 DI1_18 SI1_18 VSS nfet_06v0 w=50u l=0.7u nf=1 m=10 ad=22p as=22p pd=100.88u ps=100.88u
RVD1_18 DI1_18 D1_18 0.1
RVS1_18 SI1_18 S1_18 0.1
RD1_18 D1_17 D1_18 0.0296214
RS1_18 S1_17 S1_18 0.0296214
RJ1_18 S0_18 D1_18 0.495234
XM1_19 DI1_19 DI1_19 SI1_19 VSS nfet_06v0 w=50u l=0.7u nf=1 m=10 ad=22p as=22p pd=100.88u ps=100.88u
RVD1_19 DI1_19 D1_19 0.1
RVS1_19 SI1_19 S1_19 0.1
RD1_19 D1_18 D1_19 0.0296214
RS1_19 S1_18 S1_19 0.0296214
RJ1_19 S0_19 D1_19 0.495234
XM1_20 DI1_20 DI1_20 SI1_20 VSS nfet_06v0 w=50u l=0.7u nf=1 m=10 ad=22p as=22p pd=100.88u ps=100.88u
RVD1_20 DI1_20 D1_20 0.1
RVS1_20 SI1_20 S1_20 0.1
RD1_20 D1_19 D1_20 0.0296214
RS1_20 S1_19 S1_20 0.0296214
RJ1_20 S0_20 D1_20 0.495234
XM1_21 DI1_21 DI1_21 SI1_21 VSS nfet_06v0 w=50u l=0.7u nf=1 m=10 ad=22p as=22p pd=100.88u ps=100.88u
RVD1_21 DI1_21 D1_21 0.1
RVS1_21 SI1_21 S1_21 0.1
RD1_21 D1_20 D1_21 0.0296214
RS1_21 S1_20 S1_21 0.0296214
RJ1_21 S0_21 D1_21 0.495234
XM1_22 DI1_22 DI1_22 SI1_22 VSS nfet_06v0 w=50u l=0.7u nf=1 m=10 ad=22p as=22p pd=100.88u ps=100.88u
RVD1_22 DI1_22 D1_22 0.1
RVS1_22 SI1_22 S1_22 0.1
RD1_22 D1_21 D1_22 0.0296214
RS1_22 S1_21 S1_22 0.0296214
RJ1_22 S0_22 D1_22 0.495234
XM1_23 DI1_23 DI1_23 SI1_23 VSS nfet_06v0 w=50u l=0.7u nf=1 m=10 ad=22p as=22p pd=100.88u ps=100.88u
RVD1_23 DI1_23 D1_23 0.1
RVS1_23 SI1_23 S1_23 0.1
RD1_23 D1_22 D1_23 0.0296214
RS1_23 S1_22 S1_23 0.0296214
RJ1_23 S0_23 D1_23 0.495234
XM2_0 DI2_0 DI2_0 SI2_0 VSS nfet_06v0 w=50u l=0.7u nf=1 m=10 ad=22p as=22p pd=100.88u ps=100.88u
RVD2_0 DI2_0 D2_0 0.1
RVS2_0 SI2_0 S2_0 0.1
RJ2_0 S1_0 D2_0 0.495234
XM2_1 DI2_1 DI2_1 SI2_1 VSS nfet_06v0 w=50u l=0.7u nf=1 m=10 ad=22p as=22p pd=100.88u ps=100.88u
RVD2_1 DI2_1 D2_1 0.1
RVS2_1 SI2_1 S2_1 0.1
RD2_1 D2_0 D2_1 0.0296214
RS2_1 S2_0 S2_1 0.0296214
RJ2_1 S1_1 D2_1 0.495234
XM2_2 DI2_2 DI2_2 SI2_2 VSS nfet_06v0 w=50u l=0.7u nf=1 m=10 ad=22p as=22p pd=100.88u ps=100.88u
RVD2_2 DI2_2 D2_2 0.1
RVS2_2 SI2_2 S2_2 0.1
RD2_2 D2_1 D2_2 0.0296214
RS2_2 S2_1 S2_2 0.0296214
RJ2_2 S1_2 D2_2 0.495234
XM2_3 DI2_3 DI2_3 SI2_3 VSS nfet_06v0 w=50u l=0.7u nf=1 m=10 ad=22p as=22p pd=100.88u ps=100.88u
RVD2_3 DI2_3 D2_3 0.1
RVS2_3 SI2_3 S2_3 0.1
RD2_3 D2_2 D2_3 0.0296214
RS2_3 S2_2 S2_3 0.0296214
RJ2_3 S1_3 D2_3 0.495234
XM2_4 DI2_4 DI2_4 SI2_4 VSS nfet_06v0 w=50u l=0.7u nf=1 m=10 ad=22p as=22p pd=100.88u ps=100.88u
RVD2_4 DI2_4 D2_4 0.1
RVS2_4 SI2_4 S2_4 0.1
RD2_4 D2_3 D2_4 0.0296214
RS2_4 S2_3 S2_4 0.0296214
RJ2_4 S1_4 D2_4 0.495234
XM2_5 DI2_5 DI2_5 SI2_5 VSS nfet_06v0 w=50u l=0.7u nf=1 m=10 ad=22p as=22p pd=100.88u ps=100.88u
RVD2_5 DI2_5 D2_5 0.1
RVS2_5 SI2_5 S2_5 0.1
RD2_5 D2_4 D2_5 0.0296214
RS2_5 S2_4 S2_5 0.0296214
RJ2_5 S1_5 D2_5 0.495234
XM2_6 DI2_6 DI2_6 SI2_6 VSS nfet_06v0 w=50u l=0.7u nf=1 m=10 ad=22p as=22p pd=100.88u ps=100.88u
RVD2_6 DI2_6 D2_6 0.1
RVS2_6 SI2_6 S2_6 0.1
RD2_6 D2_5 D2_6 0.0296214
RS2_6 S2_5 S2_6 0.0296214
RJ2_6 S1_6 D2_6 0.495234
XM2_7 DI2_7 DI2_7 SI2_7 VSS nfet_06v0 w=50u l=0.7u nf=1 m=10 ad=22p as=22p pd=100.88u ps=100.88u
RVD2_7 DI2_7 D2_7 0.1
RVS2_7 SI2_7 S2_7 0.1
RD2_7 D2_6 D2_7 0.0296214
RS2_7 S2_6 S2_7 0.0296214
RJ2_7 S1_7 D2_7 0.495234
XM2_8 DI2_8 DI2_8 SI2_8 VSS nfet_06v0 w=50u l=0.7u nf=1 m=10 ad=22p as=22p pd=100.88u ps=100.88u
RVD2_8 DI2_8 D2_8 0.1
RVS2_8 SI2_8 S2_8 0.1
RD2_8 D2_7 D2_8 0.0296214
RS2_8 S2_7 S2_8 0.0296214
RJ2_8 S1_8 D2_8 0.495234
XM2_9 DI2_9 DI2_9 SI2_9 VSS nfet_06v0 w=50u l=0.7u nf=1 m=10 ad=22p as=22p pd=100.88u ps=100.88u
RVD2_9 DI2_9 D2_9 0.1
RVS2_9 SI2_9 S2_9 0.1
RD2_9 D2_8 D2_9 0.0296214
RS2_9 S2_8 S2_9 0.0296214
RJ2_9 S1_9 D2_9 0.495234
XM2_10 DI2_10 DI2_10 SI2_10 VSS nfet_06v0 w=50u l=0.7u nf=1 m=10 ad=22p as=22p pd=100.88u ps=100.88u
RVD2_10 DI2_10 D2_10 0.1
RVS2_10 SI2_10 S2_10 0.1
RD2_10 D2_9 D2_10 0.0296214
RS2_10 S2_9 S2_10 0.0296214
RJ2_10 S1_10 D2_10 0.495234
XM2_11 DI2_11 DI2_11 SI2_11 VSS nfet_06v0 w=50u l=0.7u nf=1 m=10 ad=22p as=22p pd=100.88u ps=100.88u
RVD2_11 DI2_11 D2_11 0.1
RVS2_11 SI2_11 S2_11 0.1
RD2_11 D2_10 D2_11 0.0296214
RS2_11 S2_10 S2_11 0.0296214
RJ2_11 S1_11 D2_11 0.495234
XM2_12 DI2_12 DI2_12 SI2_12 VSS nfet_06v0 w=50u l=0.7u nf=1 m=10 ad=22p as=22p pd=100.88u ps=100.88u
RVD2_12 DI2_12 D2_12 0.1
RVS2_12 SI2_12 S2_12 0.1
RD2_12 D2_11 D2_12 0.0296214
RS2_12 S2_11 S2_12 0.0296214
RJ2_12 S1_12 D2_12 0.495234
XM2_13 DI2_13 DI2_13 SI2_13 VSS nfet_06v0 w=50u l=0.7u nf=1 m=10 ad=22p as=22p pd=100.88u ps=100.88u
RVD2_13 DI2_13 D2_13 0.1
RVS2_13 SI2_13 S2_13 0.1
RD2_13 D2_12 D2_13 0.0296214
RS2_13 S2_12 S2_13 0.0296214
RJ2_13 S1_13 D2_13 0.495234
XM2_14 DI2_14 DI2_14 SI2_14 VSS nfet_06v0 w=50u l=0.7u nf=1 m=10 ad=22p as=22p pd=100.88u ps=100.88u
RVD2_14 DI2_14 D2_14 0.1
RVS2_14 SI2_14 S2_14 0.1
RD2_14 D2_13 D2_14 0.0296214
RS2_14 S2_13 S2_14 0.0296214
RJ2_14 S1_14 D2_14 0.495234
XM2_15 DI2_15 DI2_15 SI2_15 VSS nfet_06v0 w=50u l=0.7u nf=1 m=10 ad=22p as=22p pd=100.88u ps=100.88u
RVD2_15 DI2_15 D2_15 0.1
RVS2_15 SI2_15 S2_15 0.1
RD2_15 D2_14 D2_15 0.0296214
RS2_15 S2_14 S2_15 0.0296214
RJ2_15 S1_15 D2_15 0.495234
XM2_16 DI2_16 DI2_16 SI2_16 VSS nfet_06v0 w=50u l=0.7u nf=1 m=10 ad=22p as=22p pd=100.88u ps=100.88u
RVD2_16 DI2_16 D2_16 0.1
RVS2_16 SI2_16 S2_16 0.1
RD2_16 D2_15 D2_16 0.0296214
RS2_16 S2_15 S2_16 0.0296214
RJ2_16 S1_16 D2_16 0.495234
XM2_17 DI2_17 DI2_17 SI2_17 VSS nfet_06v0 w=50u l=0.7u nf=1 m=10 ad=22p as=22p pd=100.88u ps=100.88u
RVD2_17 DI2_17 D2_17 0.1
RVS2_17 SI2_17 S2_17 0.1
RD2_17 D2_16 D2_17 0.0296214
RS2_17 S2_16 S2_17 0.0296214
RJ2_17 S1_17 D2_17 0.495234
XM2_18 DI2_18 DI2_18 SI2_18 VSS nfet_06v0 w=50u l=0.7u nf=1 m=10 ad=22p as=22p pd=100.88u ps=100.88u
RVD2_18 DI2_18 D2_18 0.1
RVS2_18 SI2_18 S2_18 0.1
RD2_18 D2_17 D2_18 0.0296214
RS2_18 S2_17 S2_18 0.0296214
RJ2_18 S1_18 D2_18 0.495234
XM2_19 DI2_19 DI2_19 SI2_19 VSS nfet_06v0 w=50u l=0.7u nf=1 m=10 ad=22p as=22p pd=100.88u ps=100.88u
RVD2_19 DI2_19 D2_19 0.1
RVS2_19 SI2_19 S2_19 0.1
RD2_19 D2_18 D2_19 0.0296214
RS2_19 S2_18 S2_19 0.0296214
RJ2_19 S1_19 D2_19 0.495234
XM2_20 DI2_20 DI2_20 SI2_20 VSS nfet_06v0 w=50u l=0.7u nf=1 m=10 ad=22p as=22p pd=100.88u ps=100.88u
RVD2_20 DI2_20 D2_20 0.1
RVS2_20 SI2_20 S2_20 0.1
RD2_20 D2_19 D2_20 0.0296214
RS2_20 S2_19 S2_20 0.0296214
RJ2_20 S1_20 D2_20 0.495234
XM2_21 DI2_21 DI2_21 SI2_21 VSS nfet_06v0 w=50u l=0.7u nf=1 m=10 ad=22p as=22p pd=100.88u ps=100.88u
RVD2_21 DI2_21 D2_21 0.1
RVS2_21 SI2_21 S2_21 0.1
RD2_21 D2_20 D2_21 0.0296214
RS2_21 S2_20 S2_21 0.0296214
RJ2_21 S1_21 D2_21 0.495234
XM2_22 DI2_22 DI2_22 SI2_22 VSS nfet_06v0 w=50u l=0.7u nf=1 m=10 ad=22p as=22p pd=100.88u ps=100.88u
RVD2_22 DI2_22 D2_22 0.1
RVS2_22 SI2_22 S2_22 0.1
RD2_22 D2_21 D2_22 0.0296214
RS2_22 S2_21 S2_22 0.0296214
RJ2_22 S1_22 D2_22 0.495234
XM2_23 DI2_23 DI2_23 SI2_23 VSS nfet_06v0 w=50u l=0.7u nf=1 m=10 ad=22p as=22p pd=100.88u ps=100.88u
RVD2_23 DI2_23 D2_23 0.1
RVS2_23 SI2_23 S2_23 0.1
RD2_23 D2_22 D2_23 0.0296214
RS2_23 S2_22 S2_23 0.0296214
RJ2_23 S1_23 D2_23 0.495234
RRAILSTRAP RAIL RAILIN 0.142177
RRAILIN0 RAILIN D0_0 0.004
RRAILIN1 RAILIN D0_1 0.004
RRAILIN2 RAILIN D0_2 0.004
RRAILIN3 RAILIN D0_3 0.004
RVSSSTRAP VSSOUT VSS 0.256896
RVSSOUT7 S2_7 VSSOUT 0.003
RVSSOUT8 S2_8 VSSOUT 0.003
RVSSOUT9 S2_9 VSSOUT 0.003
.ends rail_shunt_flat
