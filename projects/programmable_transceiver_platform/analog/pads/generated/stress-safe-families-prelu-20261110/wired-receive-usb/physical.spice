.subckt tx_protected_pad PAD_P PAD_N VDD VSS TERM_VCM TERM_ENABLE DIFF_ENABLE DIV_ENABLE BYPASS_ENABLE RX_P RX_N HS_PBIAS HS_P HS_N FS_HIGH_P FS_HIGH_N FS_LOW_P FS_LOW_N PULLUP_P PULLUP_N PULLDOWN_P PULLDOWN_N ATB_ESD_RAIL
XPHYSICAL PAD_P PAD_N VDD VSS TERM_VCM TERM_ENABLE DIFF_ENABLE DIV_ENABLE BYPASS_ENABLE RX_P RX_N HS_PBIAS HS_P HS_N FS_HIGH_P FS_HIGH_N FS_LOW_P FS_LOW_N PULLUP_P PULLUP_N PULLDOWN_P PULLDOWN_N ESD_RAIL ATB_ESD_RAIL combined_flat
.ends tx_protected_pad
* NGSPICE file created from combined_flat.ext - technology: gf180mcuD

.subckt combined_flat PAD_P PAD_N VDD VSS TERM_VCM TERM_ENABLE DIFF_ENABLE DIV_ENABLE
+ BYPASS_ENABLE RX_P RX_N HS_PBIAS HS_P HS_N FS_HIGH_P FS_HIGH_N FS_LOW_P FS_LOW_N
+ PULLUP_P PULLUP_N PULLDOWN_P PULLDOWN_N ESD_RAIL ATB_ESD_RAIL
X0 VSS a_41684_160275# a_41684_160275# VSS nfet_06v0 ad=13p pd=50.52u as=13p ps=50.52u w=50u l=0.7u
X1 a_41684_148611# ESD_RAIL ESD_RAIL VSS nfet_06v0 ad=13p pd=50.52u as=13p ps=50.52u w=50u l=0.7u
X2 VSS a_42245_90628# ESD_RAIL VSS nfet_06v0 ad=13p pd=50.52u as=13p ps=50.52u w=50u l=0.7u
X3 ESD_RAIL ESD_RAIL a_41684_148611# VSS nfet_06v0 ad=13p pd=50.52u as=13p ps=50.52u w=50u l=0.7u
X4 FS_N_OUT FS_N_GATE FS_N_WELL FS_N_WELL pfet_03v3 ad=6.16p pd=28.88u as=6.16p ps=28.88u w=14u l=0.28u
X5 a_42245_90628# a_44789_117064# VSS VSS nfet_06v0 ad=1.3p pd=5.52u as=1.3p ps=5.52u w=5u l=0.7u
X6 ESD_RAIL a_44789_117064# a_42245_90628# ESD_RAIL pfet_06v0 ad=1.3p pd=5.52u as=1.3p ps=5.52u w=5u l=0.7u
X7 VSS a_41684_160275# a_41684_160275# VSS nfet_06v0 ad=13p pd=50.52u as=13p ps=50.52u w=50u l=0.7u
X8 a_41684_148611# ESD_RAIL ESD_RAIL VSS nfet_06v0 ad=13p pd=50.52u as=13p ps=50.52u w=50u l=0.7u
X9 TERM_P_R TERM_GATE_P TERM_VCM VSS nfet_03v3 ad=8.8p pd=40.88u as=8.8p ps=40.88u w=20u l=0.28u
X10 a_41684_160275# a_41684_160275# VSS VSS nfet_06v0 ad=13p pd=50.52u as=13p ps=50.52u w=50u l=0.7u
X11 ESD_RAIL a_42245_90628# VSS VSS nfet_06v0 ad=13p pd=50.52u as=13p ps=50.52u w=50u l=0.7u
X12 ESD_RAIL ESD_RAIL a_41684_148611# VSS nfet_06v0 ad=13p pd=50.52u as=13p ps=50.52u w=50u l=0.7u
X13 a_42245_90628# a_44789_117064# ESD_RAIL ESD_RAIL pfet_06v0 ad=1.3p pd=5.52u as=1.3p ps=5.52u w=5u l=0.7u
X14 ESD_RAIL a_41005_131545# a_43813_117064# ESD_RAIL pfet_06v0 ad=1.3p pd=5.52u as=1.3p ps=5.52u w=5u l=0.7u
X15 HS_N_5 HS_N PAD_N VSS nfet_06v0 ad=8.8p pd=40.88u as=8.8p ps=40.88u w=20u l=0.7u
X16 a_41684_160275# a_41684_160275# VSS VSS nfet_06v0 ad=13p pd=50.52u as=13p ps=50.52u w=50u l=0.7u
X17 TERM_GATE_P TERM_GATE_P_BLEED_0 VSS ppolyf_u_1k r_width=1u r_length=12.5u
X18 ESD_RAIL ESD_RAIL a_41684_148611# VSS nfet_06v0 ad=13p pd=50.52u as=13p ps=50.52u w=50u l=0.7u
X19 FS_P_GATE FS_HIGH_P FS_P_WELL FS_P_WELL pfet_03v3 ad=1.76p pd=8.88u as=1.76p ps=8.88u w=4u l=0.28u
X20 a_41684_160275# a_41684_160275# VSS VSS nfet_06v0 ad=13p pd=50.52u as=13p ps=50.52u w=50u l=0.7u
X21 a_41684_148611# a_41684_148611# a_41684_160275# VSS nfet_06v0 ad=13p pd=50.52u as=13p ps=50.52u w=50u l=0.7u
X22 a_41684_160275# a_41684_160275# VSS VSS nfet_06v0 ad=13p pd=50.52u as=13p ps=50.52u w=50u l=0.7u
X23 a_41684_160275# a_41684_148611# a_41684_148611# VSS nfet_06v0 ad=13p pd=50.52u as=13p ps=50.52u w=50u l=0.7u
X24 a_41684_160275# a_41684_160275# VSS VSS nfet_06v0 ad=13p pd=50.52u as=13p ps=50.52u w=50u l=0.7u
X25 ESD_RAIL ESD_RAIL a_41684_148611# VSS nfet_06v0 ad=13p pd=50.52u as=13p ps=50.52u w=50u l=0.7u
X26 ESD_RAIL ATB_ESD_RAIL VSS ppolyf_u_1k_6p0 r_width=1u r_length=0.47474m
X27 FS_P_CONTROL_S VDD VSS VSS nfet_03v3 ad=1.76p pd=8.88u as=1.76p ps=8.88u w=4u l=0.28u
X28 a_41684_148611# a_41684_148611# a_41684_160275# VSS nfet_06v0 ad=13p pd=50.52u as=13p ps=50.52u w=50u l=0.7u
X29 a_41684_148611# ESD_RAIL ESD_RAIL VSS nfet_06v0 ad=13p pd=50.52u as=13p ps=50.52u w=50u l=0.7u
X30 a_41684_160275# a_41684_148611# a_41684_148611# VSS nfet_06v0 ad=13p pd=50.52u as=13p ps=50.52u w=50u l=0.7u
X31 ESD_RAIL a_42245_90628# VSS VSS nfet_06v0 ad=13p pd=50.52u as=13p ps=50.52u w=50u l=0.7u
X32 a_42245_90628# a_44789_117064# ESD_RAIL ESD_RAIL pfet_06v0 ad=1.3p pd=5.52u as=1.3p ps=5.52u w=5u l=0.7u
X33 a_41684_148611# ESD_RAIL ESD_RAIL VSS nfet_06v0 ad=13p pd=50.52u as=13p ps=50.52u w=50u l=0.7u
X34 ESD_RAIL ESD_RAIL a_41684_148611# VSS nfet_06v0 ad=13p pd=50.52u as=13p ps=50.52u w=50u l=0.7u
X35 HS_P_4 HS_PBIAS VDD VDD pfet_03v3 ad=8.8p pd=40.88u as=8.8p ps=40.88u w=20u l=1u
X36 a_41684_148611# ESD_RAIL ESD_RAIL VSS nfet_06v0 ad=13p pd=50.52u as=13p ps=50.52u w=50u l=0.7u
D0 VSS FS_HIGH_P diode_nd2ps_03v3 pj=5.76u area=2.0736p
X37 a_41684_148611# a_41684_148611# a_41684_160275# VSS nfet_06v0 ad=13p pd=50.52u as=13p ps=50.52u w=50u l=0.7u
X38 PULLUP_N_BLEED_6 PULLUP_N_GATE VSS ppolyf_u_1k r_width=1u r_length=12.5u
X39 TERM_N_R TERM_GATE_N TERM_VCM VSS nfet_03v3 ad=8.8p pd=40.88u as=8.8p ps=40.88u w=20u l=0.28u
X40 a_41684_148611# a_41684_148611# a_41684_160275# VSS nfet_06v0 ad=13p pd=50.52u as=13p ps=50.52u w=50u l=0.7u
X41 a_41684_160275# a_41684_148611# a_41684_148611# VSS nfet_06v0 ad=13p pd=50.52u as=13p ps=50.52u w=50u l=0.7u
X42 a_41684_148611# a_41684_148611# a_41684_160275# VSS nfet_06v0 ad=13p pd=50.52u as=13p ps=50.52u w=50u l=0.7u
X43 a_41684_148611# ESD_RAIL ESD_RAIL VSS nfet_06v0 ad=13p pd=50.52u as=13p ps=50.52u w=50u l=0.7u
X44 PULLUP_P_CONTROL_S VDD VSS VSS nfet_03v3 ad=1.76p pd=8.88u as=1.76p ps=8.88u w=4u l=0.28u
X45 a_41684_148611# a_41684_148611# a_41684_160275# VSS nfet_06v0 ad=13p pd=50.52u as=13p ps=50.52u w=50u l=0.7u
X46 a_41684_160275# a_41684_148611# a_41684_148611# VSS nfet_06v0 ad=13p pd=50.52u as=13p ps=50.52u w=50u l=0.7u
X47 TERM_P_R TERM_GATE_P TERM_VCM VSS nfet_03v3 ad=8.8p pd=40.88u as=8.8p ps=40.88u w=20u l=0.28u
X48 a_41684_160275# a_41684_148611# a_41684_148611# VSS nfet_06v0 ad=13p pd=50.52u as=13p ps=50.52u w=50u l=0.7u
X49 ESD_RAIL a_42245_90628# VSS VSS nfet_06v0 ad=13p pd=50.52u as=13p ps=50.52u w=50u l=0.7u
X50 VDD FS_P_GATE FS_P_WELL FS_P_WELL pfet_03v3 ad=6.16p pd=28.88u as=6.16p ps=28.88u w=14u l=0.28u
X51 a_41684_148611# a_41684_148611# a_41684_160275# VSS nfet_06v0 ad=13p pd=50.52u as=13p ps=50.52u w=50u l=0.7u
X52 PULLUP_N_OUT PULLUP_N_GATE PULLUP_N_WELL PULLUP_N_WELL pfet_03v3 ad=8.8p pd=40.88u as=8.8p ps=40.88u w=20u l=0.28u
X53 TERM_N_R TERM_GATE_N TERM_VCM VSS nfet_03v3 ad=8.8p pd=40.88u as=8.8p ps=40.88u w=20u l=0.28u
X54 a_41684_148611# ESD_RAIL ESD_RAIL VSS nfet_06v0 ad=13p pd=50.52u as=13p ps=50.52u w=50u l=0.7u
X55 HS_N_4 HS_N PAD_N VSS nfet_06v0 ad=8.8p pd=40.88u as=8.8p ps=40.88u w=20u l=0.7u
X56 a_41684_160275# a_41684_148611# a_41684_148611# VSS nfet_06v0 ad=13p pd=50.52u as=13p ps=50.52u w=50u l=0.7u
X57 a_41684_160275# a_41684_148611# a_41684_148611# VSS nfet_06v0 ad=13p pd=50.52u as=13p ps=50.52u w=50u l=0.7u
X58 ESD_RAIL a_42245_90628# VSS VSS nfet_06v0 ad=13p pd=50.52u as=13p ps=50.52u w=50u l=0.7u
X59 ESD_RAIL ESD_RAIL a_41684_148611# VSS nfet_06v0 ad=13p pd=50.52u as=13p ps=50.52u w=50u l=0.7u
X60 a_41684_148611# a_41684_148611# a_41684_160275# VSS nfet_06v0 ad=13p pd=50.52u as=13p ps=50.52u w=50u l=0.7u
X61 VDD FS_P_GATE FS_P_WELL FS_P_WELL pfet_03v3 ad=6.16p pd=28.88u as=6.16p ps=28.88u w=14u l=0.28u
X62 a_41684_160275# a_41684_160275# VSS VSS nfet_06v0 ad=13p pd=50.52u as=13p ps=50.52u w=50u l=0.7u
X63 PULLUP_N_OUT PULLUP_N_GATE PULLUP_N_WELL PULLUP_N_WELL pfet_03v3 ad=8.8p pd=40.88u as=8.8p ps=40.88u w=20u l=0.28u
X64 VDD FS_N_GATE FS_N_WELL FS_N_WELL pfet_03v3 ad=6.16p pd=28.88u as=6.16p ps=28.88u w=14u l=0.28u
X65 ESD_RAIL ESD_RAIL a_41684_148611# VSS nfet_06v0 ad=13p pd=50.52u as=13p ps=50.52u w=50u l=0.7u
X66 ESD_RAIL ESD_RAIL a_41684_148611# VSS nfet_06v0 ad=13p pd=50.52u as=13p ps=50.52u w=50u l=0.7u
X67 a_41684_160275# a_41684_148611# a_41684_148611# VSS nfet_06v0 ad=13p pd=50.52u as=13p ps=50.52u w=50u l=0.7u
D1 PAD_N ESD_RAIL diode_pd2nw_06v0 pj=51.8u area=22.5p
X68 FS_N_GATE VDD FS_N_WELL FS_N_WELL pfet_03v3 ad=1.76p pd=8.88u as=1.76p ps=8.88u w=4u l=0.28u
X69 a_41684_148611# a_41684_148611# a_41684_160275# VSS nfet_06v0 ad=13p pd=50.52u as=13p ps=50.52u w=50u l=0.7u
X70 VDD FS_N_GATE FS_N_WELL FS_N_WELL pfet_03v3 ad=6.16p pd=28.88u as=6.16p ps=28.88u w=14u l=0.28u
X71 FS_P_OUT FS_P_GATE FS_P_WELL FS_P_WELL pfet_03v3 ad=6.16p pd=28.88u as=6.16p ps=28.88u w=14u l=0.28u
X72 a_41684_160275# a_41684_148611# a_41684_148611# VSS nfet_06v0 ad=13p pd=50.52u as=13p ps=50.52u w=50u l=0.7u
X73 ESD_RAIL ESD_RAIL a_41684_148611# VSS nfet_06v0 ad=13p pd=50.52u as=13p ps=50.52u w=50u l=0.7u
X74 TERM_OR_N_S TERM_ENABLE VDD VDD pfet_03v3 ad=1.76p pd=8.88u as=1.76p ps=8.88u w=4u l=0.28u
X75 a_41005_131825# a_53878_132105# ESD_RAIL ppolyf_u r_width=0.8u r_length=63.855u
X76 ESD_RAIL ESD_RAIL a_41684_148611# VSS nfet_06v0 ad=13p pd=50.52u as=13p ps=50.52u w=50u l=0.7u
X77 PULLUP_P_BLEED_1 PULLUP_P_BLEED_2 VSS ppolyf_u_1k r_width=1u r_length=12.5u
X78 a_41684_148611# a_41684_148611# a_41684_160275# VSS nfet_06v0 ad=13p pd=50.52u as=13p ps=50.52u w=50u l=0.7u
X79 a_41684_160275# a_41684_148611# a_41684_148611# VSS nfet_06v0 ad=13p pd=50.52u as=13p ps=50.52u w=50u l=0.7u
X80 a_41684_148611# a_41684_148611# a_41684_160275# VSS nfet_06v0 ad=13p pd=50.52u as=13p ps=50.52u w=50u l=0.7u
X81 a_41005_131545# VSS cap_mim_2f0_m4m5_noshield c_width=31.6u c_length=31.6u
X82 a_41684_160275# a_41684_160275# VSS VSS nfet_06v0 ad=13p pd=50.52u as=13p ps=50.52u w=50u l=0.7u
X83 a_41684_160275# a_41684_148611# a_41684_148611# VSS nfet_06v0 ad=13p pd=50.52u as=13p ps=50.52u w=50u l=0.7u
X84 a_41684_148611# a_41684_148611# a_41684_160275# VSS nfet_06v0 ad=13p pd=50.52u as=13p ps=50.52u w=50u l=0.7u
X85 VSS a_41684_160275# a_41684_160275# VSS nfet_06v0 ad=13p pd=50.52u as=13p ps=50.52u w=50u l=0.7u
X86 a_41684_160275# a_41684_148611# a_41684_148611# VSS nfet_06v0 ad=13p pd=50.52u as=13p ps=50.52u w=50u l=0.7u
X87 ESD_RAIL a_42245_90628# VSS VSS nfet_06v0 ad=13p pd=50.52u as=13p ps=50.52u w=50u l=0.7u
X88 a_41684_148611# a_41684_148611# a_41684_160275# VSS nfet_06v0 ad=13p pd=50.52u as=13p ps=50.52u w=50u l=0.7u
X89 a_41684_148611# a_41684_148611# a_41684_160275# VSS nfet_06v0 ad=13p pd=50.52u as=13p ps=50.52u w=50u l=0.7u
X90 a_42245_90628# a_44789_117064# ESD_RAIL ESD_RAIL pfet_06v0 ad=1.3p pd=5.52u as=1.3p ps=5.52u w=5u l=0.7u
X91 PULLDOWN_P_R PULLDOWN_P VSS VSS nfet_03v3 ad=3.52p pd=16.88u as=3.52p ps=16.88u w=8u l=0.28u
X92 a_41684_160275# a_41684_160275# VSS VSS nfet_06v0 ad=13p pd=50.52u as=13p ps=50.52u w=50u l=0.7u
X93 a_41684_160275# a_41684_148611# a_41684_148611# VSS nfet_06v0 ad=13p pd=50.52u as=13p ps=50.52u w=50u l=0.7u
X94 VSS a_41684_160275# a_41684_160275# VSS nfet_06v0 ad=13p pd=50.52u as=13p ps=50.52u w=50u l=0.7u
X95 a_41684_160275# a_41684_148611# a_41684_148611# VSS nfet_06v0 ad=13p pd=50.52u as=13p ps=50.52u w=50u l=0.7u
X96 a_41684_148611# a_41684_148611# a_41684_160275# VSS nfet_06v0 ad=13p pd=50.52u as=13p ps=50.52u w=50u l=0.7u
X97 VSS a_41684_160275# a_41684_160275# VSS nfet_06v0 ad=13p pd=50.52u as=13p ps=50.52u w=50u l=0.7u
X98 a_41684_148611# a_41684_148611# a_41684_160275# VSS nfet_06v0 ad=13p pd=50.52u as=13p ps=50.52u w=50u l=0.7u
X99 a_41684_160275# a_41684_148611# a_41684_148611# VSS nfet_06v0 ad=13p pd=50.52u as=13p ps=50.52u w=50u l=0.7u
X100 a_41684_148611# a_41684_148611# a_41684_160275# VSS nfet_06v0 ad=13p pd=50.52u as=13p ps=50.52u w=50u l=0.7u
X101 a_41684_160275# a_41684_160275# VSS VSS nfet_06v0 ad=13p pd=50.52u as=13p ps=50.52u w=50u l=0.7u
X102 VSS a_42245_90628# ESD_RAIL VSS nfet_06v0 ad=13p pd=50.52u as=13p ps=50.52u w=50u l=0.7u
X103 ESD_RAIL a_42245_90628# VSS VSS nfet_06v0 ad=13p pd=50.52u as=13p ps=50.52u w=50u l=0.7u
X104 a_41684_160275# a_41684_148611# a_41684_148611# VSS nfet_06v0 ad=13p pd=50.52u as=13p ps=50.52u w=50u l=0.7u
X105 a_41684_160275# a_41684_148611# a_41684_148611# VSS nfet_06v0 ad=13p pd=50.52u as=13p ps=50.52u w=50u l=0.7u
X106 VSS a_41684_160275# a_41684_160275# VSS nfet_06v0 ad=13p pd=50.52u as=13p ps=50.52u w=50u l=0.7u
X107 a_41684_148611# a_41684_148611# a_41684_160275# VSS nfet_06v0 ad=13p pd=50.52u as=13p ps=50.52u w=50u l=0.7u
X108 ESD_RAIL a_44789_117064# a_42245_90628# ESD_RAIL pfet_06v0 ad=1.3p pd=5.52u as=1.3p ps=5.52u w=5u l=0.7u
X109 a_42245_90628# a_44789_117064# ESD_RAIL ESD_RAIL pfet_06v0 ad=1.3p pd=5.52u as=1.3p ps=5.52u w=5u l=0.7u
X110 a_41684_160275# a_41684_160275# VSS VSS nfet_06v0 ad=13p pd=50.52u as=13p ps=50.52u w=50u l=0.7u
X111 a_41684_148611# a_41684_148611# a_41684_160275# VSS nfet_06v0 ad=13p pd=50.52u as=13p ps=50.52u w=50u l=0.7u
X112 ESD_RAIL ESD_RAIL a_41684_148611# VSS nfet_06v0 ad=13p pd=50.52u as=13p ps=50.52u w=50u l=0.7u
D2 PAD_P ESD_RAIL diode_pd2nw_06v0 pj=51.8u area=22.5p
X113 VSS a_44789_117064# a_42245_90628# VSS nfet_06v0 ad=2.2p pd=10.88u as=1.3p ps=5.52u w=5u l=0.7u
X114 FS_P_OUT FS_P_GATE FS_P_WELL FS_P_WELL pfet_03v3 ad=6.16p pd=28.88u as=6.16p ps=28.88u w=14u l=0.28u
X115 a_41684_160275# a_41684_148611# a_41684_148611# VSS nfet_06v0 ad=13p pd=50.52u as=13p ps=50.52u w=50u l=0.7u
X116 ESD_RAIL a_42245_90628# VSS VSS nfet_06v0 ad=13p pd=50.52u as=13p ps=50.52u w=50u l=0.7u
X117 a_41684_160275# a_41684_148611# a_41684_148611# VSS nfet_06v0 ad=13p pd=50.52u as=13p ps=50.52u w=50u l=0.7u
X118 ESD_RAIL a_44789_117064# a_42245_90628# ESD_RAIL pfet_06v0 ad=1.3p pd=5.52u as=1.3p ps=5.52u w=5u l=0.7u
X119 VSS a_41684_160275# a_41684_160275# VSS nfet_06v0 ad=13p pd=50.52u as=13p ps=50.52u w=50u l=0.7u
X120 a_41684_160275# a_41684_160275# VSS VSS nfet_06v0 ad=13p pd=50.52u as=13p ps=50.52u w=50u l=0.7u
X121 a_41684_148611# a_41684_148611# a_41684_160275# VSS nfet_06v0 ad=13p pd=50.52u as=13p ps=50.52u w=50u l=0.7u
X122 ESD_RAIL a_42245_90628# VSS VSS nfet_06v0 ad=22p pd=0.10088m as=13p ps=50.52u w=50u l=0.7u
X123 VSS a_42245_90628# ESD_RAIL VSS nfet_06v0 ad=13p pd=50.52u as=13p ps=50.52u w=50u l=0.7u
X124 a_41684_160275# a_41684_160275# VSS VSS nfet_06v0 ad=13p pd=50.52u as=13p ps=50.52u w=50u l=0.7u
X125 VSS a_41684_160275# a_41684_160275# VSS nfet_06v0 ad=13p pd=50.52u as=13p ps=50.52u w=50u l=0.7u
X126 HS_P_9 HS_PBIAS VDD VDD pfet_03v3 ad=8.8p pd=40.88u as=8.8p ps=40.88u w=20u l=1u
X127 a_41684_148611# a_41684_148611# a_41684_160275# VSS nfet_06v0 ad=13p pd=50.52u as=13p ps=50.52u w=50u l=0.7u
X128 a_41005_132945# a_53878_133225# ESD_RAIL ppolyf_u r_width=0.8u r_length=63.855u
X129 a_41684_160275# a_41684_160275# VSS VSS nfet_06v0 ad=13p pd=50.52u as=13p ps=50.52u w=50u l=0.7u
X130 a_41684_160275# a_41684_148611# a_41684_148611# VSS nfet_06v0 ad=13p pd=50.52u as=13p ps=50.52u w=50u l=0.7u
X131 ESD_RAIL ESD_RAIL a_41684_148611# VSS nfet_06v0 ad=13p pd=50.52u as=13p ps=50.52u w=50u l=0.7u
X132 VSS a_41684_160275# a_41684_160275# VSS nfet_06v0 ad=13p pd=50.52u as=13p ps=50.52u w=50u l=0.7u
X133 a_41684_160275# a_41684_148611# a_41684_148611# VSS nfet_06v0 ad=13p pd=50.52u as=13p ps=50.52u w=50u l=0.7u
X134 a_41684_148611# ESD_RAIL ESD_RAIL VSS nfet_06v0 ad=13p pd=50.52u as=13p ps=50.52u w=50u l=0.7u
X135 a_41684_148611# a_41684_148611# a_41684_160275# VSS nfet_06v0 ad=13p pd=50.52u as=13p ps=50.52u w=50u l=0.7u
X136 a_41684_160275# a_41684_148611# a_41684_148611# VSS nfet_06v0 ad=13p pd=50.52u as=13p ps=50.52u w=50u l=0.7u
X137 a_41684_148611# a_41684_148611# a_41684_160275# VSS nfet_06v0 ad=13p pd=50.52u as=13p ps=50.52u w=50u l=0.7u
X138 a_41684_160275# a_41684_160275# VSS VSS nfet_06v0 ad=13p pd=50.52u as=13p ps=50.52u w=50u l=0.7u
X139 a_41684_160275# a_41684_148611# a_41684_148611# VSS nfet_06v0 ad=13p pd=50.52u as=13p ps=50.52u w=50u l=0.7u
X140 a_41684_160275# a_41684_148611# a_41684_148611# VSS nfet_06v0 ad=13p pd=50.52u as=13p ps=50.52u w=50u l=0.7u
X141 ESD_RAIL ESD_RAIL a_41684_148611# VSS nfet_06v0 ad=13p pd=50.52u as=13p ps=50.52u w=50u l=0.7u
X142 a_42245_90628# a_44789_117064# VSS VSS nfet_06v0 ad=1.3p pd=5.52u as=1.3p ps=5.52u w=5u l=0.7u
X143 ESD_RAIL a_44789_117064# a_42245_90628# ESD_RAIL pfet_06v0 ad=1.3p pd=5.52u as=1.3p ps=5.52u w=5u l=0.7u
X144 VSS a_41684_160275# a_41684_160275# VSS nfet_06v0 ad=13p pd=50.52u as=13p ps=50.52u w=50u l=0.7u
X145 FS_P_OUT FS_P_GATE FS_P_WELL FS_P_WELL pfet_03v3 ad=6.16p pd=28.88u as=6.16p ps=28.88u w=14u l=0.28u
X146 a_41684_148611# ESD_RAIL ESD_RAIL VSS nfet_06v0 ad=13p pd=50.52u as=13p ps=50.52u w=50u l=0.7u
X147 VDD FS_N_GATE FS_N_WELL FS_N_WELL pfet_03v3 ad=6.16p pd=28.88u as=6.16p ps=28.88u w=14u l=0.28u
X148 a_41684_160275# a_41684_160275# VSS VSS nfet_06v0 ad=13p pd=50.52u as=13p ps=50.52u w=50u l=0.7u
X149 a_41684_148611# a_41684_148611# a_41684_160275# VSS nfet_06v0 ad=13p pd=50.52u as=13p ps=50.52u w=50u l=0.7u
X150 HS_N_9 HS_N PAD_N VSS nfet_06v0 ad=8.8p pd=40.88u as=8.8p ps=40.88u w=20u l=0.7u
X151 a_42245_90628# a_44789_117064# ESD_RAIL ESD_RAIL pfet_06v0 ad=1.3p pd=5.52u as=2.2p ps=10.88u w=5u l=0.7u
X152 VSS a_41684_160275# a_41684_160275# VSS nfet_06v0 ad=13p pd=50.52u as=13p ps=50.52u w=50u l=0.7u
X153 FS_P_OUT FS_P_GATE FS_P_WELL FS_P_WELL pfet_03v3 ad=6.16p pd=28.88u as=6.16p ps=28.88u w=14u l=0.28u
X154 a_43813_117064# a_41005_131545# VSS VSS nfet_06v0 ad=2.2p pd=10.88u as=2.2p ps=10.88u w=5u l=0.7u
X155 a_41684_148611# ESD_RAIL ESD_RAIL VSS nfet_06v0 ad=13p pd=50.52u as=13p ps=50.52u w=50u l=0.7u
X156 ESD_RAIL ESD_RAIL a_41684_148611# VSS nfet_06v0 ad=13p pd=50.52u as=13p ps=50.52u w=50u l=0.7u
X157 a_41684_160275# a_41684_160275# VSS VSS nfet_06v0 ad=13p pd=50.52u as=13p ps=50.52u w=50u l=0.7u
X158 VSS a_41684_160275# a_41684_160275# VSS nfet_06v0 ad=13p pd=50.52u as=13p ps=50.52u w=50u l=0.7u
X159 VSS a_41684_160275# a_41684_160275# VSS nfet_06v0 ad=13p pd=50.52u as=13p ps=50.52u w=50u l=0.7u
X160 a_41684_148611# ESD_RAIL ESD_RAIL VSS nfet_06v0 ad=13p pd=50.52u as=13p ps=50.52u w=50u l=0.7u
X161 a_41684_160275# a_41684_160275# VSS VSS nfet_06v0 ad=13p pd=50.52u as=13p ps=50.52u w=50u l=0.7u
X162 ESD_RAIL ESD_RAIL a_41684_148611# VSS nfet_06v0 ad=13p pd=50.52u as=13p ps=50.52u w=50u l=0.7u
X163 ESD_RAIL a_42245_90628# VSS VSS nfet_06v0 ad=13p pd=50.52u as=13p ps=50.52u w=50u l=0.7u
X164 VSS a_42245_90628# ESD_RAIL VSS nfet_06v0 ad=13p pd=50.52u as=22p ps=0.10088m w=50u l=0.7u
X165 a_42245_90628# a_44789_117064# VSS VSS nfet_06v0 ad=1.3p pd=5.52u as=1.3p ps=5.52u w=5u l=0.7u
X166 HS_P_7 HS_PBIAS VDD VDD pfet_03v3 ad=8.8p pd=40.88u as=8.8p ps=40.88u w=20u l=1u
X167 VSS a_41684_160275# a_41684_160275# VSS nfet_06v0 ad=13p pd=50.52u as=13p ps=50.52u w=50u l=0.7u
X168 a_41684_148611# ESD_RAIL ESD_RAIL VSS nfet_06v0 ad=13p pd=50.52u as=13p ps=50.52u w=50u l=0.7u
X169 VSS a_43813_117064# a_44789_117064# VSS nfet_06v0 ad=1.3p pd=5.52u as=1.3p ps=5.52u w=5u l=0.7u
X170 a_42245_90628# a_44789_117064# ESD_RAIL ESD_RAIL pfet_06v0 ad=1.3p pd=5.52u as=1.3p ps=5.52u w=5u l=0.7u
X171 ESD_RAIL ESD_RAIL a_41684_148611# VSS nfet_06v0 ad=13p pd=50.52u as=13p ps=50.52u w=50u l=0.7u
X172 a_41684_160275# a_41684_160275# VSS VSS nfet_06v0 ad=13p pd=50.52u as=13p ps=50.52u w=50u l=0.7u
X173 ESD_RAIL ESD_RAIL a_41684_148611# VSS nfet_06v0 ad=13p pd=50.52u as=13p ps=50.52u w=50u l=0.7u
X174 HS_P_11 HS_P PAD_P VSS nfet_06v0 ad=8.8p pd=40.88u as=8.8p ps=40.88u w=20u l=0.7u
X175 a_41684_148611# ESD_RAIL ESD_RAIL VSS nfet_06v0 ad=13p pd=50.52u as=13p ps=50.52u w=50u l=0.7u
X176 VSS a_42245_90628# ESD_RAIL VSS nfet_06v0 ad=13p pd=50.52u as=22p ps=0.10088m w=50u l=0.7u
X177 PAD_P PULLDOWN_P_R VSS ppolyf_u_1k r_width=1u r_length=14.2u
X178 TERM_P_R TERM_GATE_P TERM_VCM VSS nfet_03v3 ad=8.8p pd=40.88u as=8.8p ps=40.88u w=20u l=0.28u
X179 a_41684_160275# a_41684_160275# VSS VSS nfet_06v0 ad=13p pd=50.52u as=13p ps=50.52u w=50u l=0.7u
X180 VSS a_41684_160275# a_41684_160275# VSS nfet_06v0 ad=13p pd=50.52u as=13p ps=50.52u w=50u l=0.7u
X181 a_41684_160275# a_41684_160275# VSS VSS nfet_06v0 ad=13p pd=50.52u as=13p ps=50.52u w=50u l=0.7u
X182 VSS a_41684_160275# a_41684_160275# VSS nfet_06v0 ad=13p pd=50.52u as=13p ps=50.52u w=50u l=0.7u
X183 PAD_P BYPASS_ENABLE RX_P VSS nfet_06v0 ad=8.8p pd=40.88u as=8.8p ps=40.88u w=20u l=0.7u
X184 ESD_RAIL ESD_RAIL a_41684_148611# VSS nfet_06v0 ad=13p pd=50.52u as=13p ps=50.52u w=50u l=0.7u
X185 HS_N_6 HS_N PAD_N VSS nfet_06v0 ad=8.8p pd=40.88u as=8.8p ps=40.88u w=20u l=0.7u
X186 a_41005_134065# a_53878_134345# ESD_RAIL ppolyf_u r_width=0.8u r_length=63.855u
X187 a_41684_148611# ESD_RAIL ESD_RAIL VSS nfet_06v0 ad=13p pd=50.52u as=13p ps=50.52u w=50u l=0.7u
X188 VDD FS_N_GATE FS_N_WELL FS_N_WELL pfet_03v3 ad=6.16p pd=28.88u as=6.16p ps=28.88u w=14u l=0.28u
X189 a_41684_160275# a_41684_160275# VSS VSS nfet_06v0 ad=13p pd=50.52u as=13p ps=50.52u w=50u l=0.7u
X190 FS_P_OUT FS_P_GATE FS_P_WELL FS_P_WELL pfet_03v3 ad=6.16p pd=28.88u as=6.16p ps=28.88u w=14u l=0.28u
D3 PAD_N ESD_RAIL diode_pd2nw_06v0 pj=51.8u area=22.5p
X191 VSS a_41684_160275# a_41684_160275# VSS nfet_06v0 ad=13p pd=50.52u as=13p ps=50.52u w=50u l=0.7u
X192 a_41684_160275# a_41684_160275# VSS VSS nfet_06v0 ad=13p pd=50.52u as=13p ps=50.52u w=50u l=0.7u
X193 ESD_RAIL a_42245_90628# VSS VSS nfet_06v0 ad=13p pd=50.52u as=13p ps=50.52u w=50u l=0.7u
X194 DIV_LOW_P DIV_ENABLE VSS VSS nfet_03v3 ad=8.8p pd=40.88u as=8.8p ps=40.88u w=20u l=0.28u
X195 ESD_RAIL ESD_RAIL a_41684_148611# VSS nfet_06v0 ad=13p pd=50.52u as=13p ps=50.52u w=50u l=0.7u
X196 a_41684_148611# ESD_RAIL ESD_RAIL VSS nfet_06v0 ad=13p pd=50.52u as=13p ps=50.52u w=50u l=0.7u
X197 VDD FS_N_GATE FS_N_WELL FS_N_WELL pfet_03v3 ad=6.16p pd=28.88u as=6.16p ps=28.88u w=14u l=0.28u
X198 a_41684_160275# a_41684_148611# a_41684_148611# VSS nfet_06v0 ad=13p pd=50.52u as=13p ps=50.52u w=50u l=0.7u
X199 FS_P_OUT FS_P_GATE FS_P_WELL FS_P_WELL pfet_03v3 ad=6.16p pd=28.88u as=6.16p ps=28.88u w=14u l=0.28u
X200 VSS a_43813_117064# a_44789_117064# VSS nfet_06v0 ad=1.3p pd=5.52u as=1.3p ps=5.52u w=5u l=0.7u
X201 ESD_RAIL ESD_RAIL a_41684_148611# VSS nfet_06v0 ad=13p pd=50.52u as=13p ps=50.52u w=50u l=0.7u
D4 PAD_P ESD_RAIL diode_pd2nw_06v0 pj=51.8u area=22.5p
X202 HS_N_7 HS_N PAD_N VSS nfet_06v0 ad=8.8p pd=40.88u as=8.8p ps=40.88u w=20u l=0.7u
X203 FS_P_BLEED_6 FS_P_GATE VSS ppolyf_u_1k r_width=1u r_length=12.5u
X204 VSS a_42245_90628# ESD_RAIL VSS nfet_06v0 ad=13p pd=50.52u as=13p ps=50.52u w=50u l=0.7u
X205 a_41684_148611# ESD_RAIL ESD_RAIL VSS nfet_06v0 ad=13p pd=50.52u as=13p ps=50.52u w=50u l=0.7u
X206 ESD_RAIL ESD_RAIL a_41684_148611# VSS nfet_06v0 ad=13p pd=50.52u as=13p ps=50.52u w=50u l=0.7u
X207 VDD PULLUP_P_GATE PULLUP_P_WELL PULLUP_P_WELL pfet_03v3 ad=8.8p pd=40.88u as=8.8p ps=40.88u w=20u l=0.28u
X208 FS_P_OUT FS_P_GATE FS_P_WELL FS_P_WELL pfet_03v3 ad=6.16p pd=28.88u as=6.16p ps=28.88u w=14u l=0.28u
X209 a_41684_160275# a_41684_148611# a_41684_148611# VSS nfet_06v0 ad=13p pd=50.52u as=13p ps=50.52u w=50u l=0.7u
X210 ESD_RAIL a_42245_90628# VSS VSS nfet_06v0 ad=13p pd=50.52u as=13p ps=50.52u w=50u l=0.7u
X211 a_41684_148611# ESD_RAIL ESD_RAIL VSS nfet_06v0 ad=13p pd=50.52u as=13p ps=50.52u w=50u l=0.7u
X212 TERM_P_R DIFF_ENABLE TERM_N_R VSS nfet_03v3 ad=8.8p pd=40.88u as=8.8p ps=40.88u w=20u l=0.28u
X213 a_41684_160275# a_41684_160275# VSS VSS nfet_06v0 ad=13p pd=50.52u as=13p ps=50.52u w=50u l=0.7u
X214 a_41684_148611# ESD_RAIL ESD_RAIL VSS nfet_06v0 ad=13p pd=50.52u as=13p ps=50.52u w=50u l=0.7u
X215 ESD_RAIL ESD_RAIL a_41684_148611# VSS nfet_06v0 ad=13p pd=50.52u as=13p ps=50.52u w=50u l=0.7u
X216 VDD FS_N_GATE FS_N_WELL FS_N_WELL pfet_03v3 ad=6.16p pd=28.88u as=6.16p ps=28.88u w=14u l=0.28u
D5 VSS TERM_ENABLE diode_nd2ps_03v3 pj=7.56u area=3.5721p
X217 TERM_OR_N_B TERM_ENABLE VSS VSS nfet_03v3 ad=0.88p pd=4.88u as=0.88p ps=4.88u w=2u l=0.28u
X218 a_41684_148611# a_41684_148611# a_41684_160275# VSS nfet_06v0 ad=13p pd=50.52u as=13p ps=50.52u w=50u l=0.7u
X219 HS_N_2 HS_N PAD_N VSS nfet_06v0 ad=8.8p pd=40.88u as=8.8p ps=40.88u w=20u l=0.7u
X220 a_41684_160275# a_41684_160275# VSS VSS nfet_06v0 ad=13p pd=50.52u as=13p ps=50.52u w=50u l=0.7u
X221 ESD_RAIL a_42245_90628# VSS VSS nfet_06v0 ad=13p pd=50.52u as=13p ps=50.52u w=50u l=0.7u
X222 a_41684_148611# ESD_RAIL ESD_RAIL VSS nfet_06v0 ad=13p pd=50.52u as=13p ps=50.52u w=50u l=0.7u
X223 ESD_RAIL ESD_RAIL a_41684_148611# VSS nfet_06v0 ad=13p pd=50.52u as=13p ps=50.52u w=50u l=0.7u
X224 HS_N_6 HS_PBIAS VDD VDD pfet_03v3 ad=8.8p pd=40.88u as=8.8p ps=40.88u w=20u l=1u
X225 a_41684_148611# a_41684_148611# a_41684_160275# VSS nfet_06v0 ad=13p pd=50.52u as=13p ps=50.52u w=50u l=0.7u
X226 PULLUP_N_OUT PULLUP_N_GATE PULLUP_N_WELL PULLUP_N_WELL pfet_03v3 ad=8.8p pd=40.88u as=8.8p ps=40.88u w=20u l=0.28u
X227 ESD_RAIL ESD_RAIL a_41684_148611# VSS nfet_06v0 ad=13p pd=50.52u as=13p ps=50.52u w=50u l=0.7u
X228 VSS a_41684_160275# a_41684_160275# VSS nfet_06v0 ad=13p pd=50.52u as=13p ps=50.52u w=50u l=0.7u
X229 a_41684_148611# ESD_RAIL ESD_RAIL VSS nfet_06v0 ad=13p pd=50.52u as=13p ps=50.52u w=50u l=0.7u
X230 a_41684_148611# ESD_RAIL ESD_RAIL VSS nfet_06v0 ad=13p pd=50.52u as=13p ps=50.52u w=50u l=0.7u
X231 ESD_RAIL ESD_RAIL a_41684_148611# VSS nfet_06v0 ad=13p pd=50.52u as=13p ps=50.52u w=50u l=0.7u
X232 a_41684_148611# a_41684_148611# a_41684_160275# VSS nfet_06v0 ad=13p pd=50.52u as=13p ps=50.52u w=50u l=0.7u
X233 ESD_RAIL ESD_RAIL a_41684_148611# VSS nfet_06v0 ad=13p pd=50.52u as=13p ps=50.52u w=50u l=0.7u
X234 a_41684_148611# ESD_RAIL ESD_RAIL VSS nfet_06v0 ad=13p pd=50.52u as=13p ps=50.52u w=50u l=0.7u
X235 HS_N_8 HS_PBIAS VDD VDD pfet_03v3 ad=8.8p pd=40.88u as=8.8p ps=40.88u w=20u l=1u
X236 FS_P_BLEED_0 FS_P_BLEED_1 VSS ppolyf_u_1k r_width=1u r_length=12.5u
X237 VSS a_41684_160275# a_41684_160275# VSS nfet_06v0 ad=13p pd=50.52u as=13p ps=50.52u w=50u l=0.7u
X238 ESD_RAIL ESD_RAIL a_41684_148611# VSS nfet_06v0 ad=13p pd=50.52u as=13p ps=50.52u w=50u l=0.7u
X239 PULLUP_N_BLEED_3 PULLUP_N_BLEED_4 VSS ppolyf_u_1k r_width=1u r_length=12.5u
X240 FS_P_OUT FS_P_GATE FS_P_WELL FS_P_WELL pfet_03v3 ad=6.16p pd=28.88u as=6.16p ps=28.88u w=14u l=0.28u
X241 FS_N_OUT PAD_N VSS ppolyf_s r_width=2u r_length=3.5u
X242 a_41684_160275# a_41684_148611# a_41684_148611# VSS nfet_06v0 ad=13p pd=50.52u as=13p ps=50.52u w=50u l=0.7u
X243 a_41684_160275# a_41684_148611# a_41684_148611# VSS nfet_06v0 ad=13p pd=50.52u as=13p ps=50.52u w=50u l=0.7u
X244 TERM_P_R DIFF_ENABLE TERM_N_R VSS nfet_03v3 ad=8.8p pd=40.88u as=8.8p ps=40.88u w=20u l=0.28u
X245 FS_P_BLEED_2 FS_P_BLEED_3 VSS ppolyf_u_1k r_width=1u r_length=12.5u
X246 a_41684_160275# a_41684_148611# a_41684_148611# VSS nfet_06v0 ad=13p pd=50.52u as=13p ps=50.52u w=50u l=0.7u
X247 TERM_OR_P_S TERM_ENABLE VDD VDD pfet_03v3 ad=1.76p pd=8.88u as=1.76p ps=8.88u w=4u l=0.28u
X248 TERM_GATE_N TERM_OR_N_B VDD VDD pfet_03v3 ad=3.52p pd=16.88u as=3.52p ps=16.88u w=8u l=0.28u
X249 VDD PULLUP_P_GATE PULLUP_P_WELL PULLUP_P_WELL pfet_03v3 ad=8.8p pd=40.88u as=8.8p ps=40.88u w=20u l=0.28u
X250 FS_P_OUT FS_P_GATE FS_P_WELL FS_P_WELL pfet_03v3 ad=6.16p pd=28.88u as=6.16p ps=28.88u w=14u l=0.28u
X251 a_41684_160275# a_41684_160275# VSS VSS nfet_06v0 ad=13p pd=50.52u as=13p ps=50.52u w=50u l=0.7u
X252 ESD_RAIL ESD_RAIL a_41684_148611# VSS nfet_06v0 ad=13p pd=50.52u as=13p ps=50.52u w=50u l=0.7u
X253 VDD FS_N_GATE FS_N_WELL FS_N_WELL pfet_03v3 ad=6.16p pd=28.88u as=6.16p ps=28.88u w=14u l=0.28u
X254 TERM_N_R TERM_GATE_N TERM_VCM VSS nfet_03v3 ad=8.8p pd=40.88u as=8.8p ps=40.88u w=20u l=0.28u
X255 ESD_RAIL ESD_RAIL a_41684_148611# VSS nfet_06v0 ad=13p pd=50.52u as=13p ps=50.52u w=50u l=0.7u
X256 HS_N_13 HS_N PAD_N VSS nfet_06v0 ad=8.8p pd=40.88u as=8.8p ps=40.88u w=20u l=0.7u
X257 FS_P_OUT FS_P_GATE FS_P_WELL FS_P_WELL pfet_03v3 ad=6.16p pd=28.88u as=6.16p ps=28.88u w=14u l=0.28u
X258 a_41684_148611# a_41684_148611# a_41684_160275# VSS nfet_06v0 ad=13p pd=50.52u as=13p ps=50.52u w=50u l=0.7u
X259 a_41684_148611# a_41684_148611# a_41684_160275# VSS nfet_06v0 ad=13p pd=50.52u as=13p ps=50.52u w=50u l=0.7u
X260 HS_N_2 HS_PBIAS VDD VDD pfet_03v3 ad=8.8p pd=40.88u as=8.8p ps=40.88u w=20u l=1u
X261 VSS a_42245_90628# ESD_RAIL VSS nfet_06v0 ad=13p pd=50.52u as=13p ps=50.52u w=50u l=0.7u
X262 VSS a_41684_160275# a_41684_160275# VSS nfet_06v0 ad=13p pd=50.52u as=13p ps=50.52u w=50u l=0.7u
X263 VCM_LOW_OK TERM_VCM VDD VDD pfet_03v3 ad=0.88p pd=4.88u as=0.88p ps=4.88u w=2u l=0.28u
X264 a_41684_148611# ESD_RAIL ESD_RAIL VSS nfet_06v0 ad=13p pd=50.52u as=13p ps=50.52u w=50u l=0.7u
X265 a_41684_148611# a_41684_148611# a_41684_160275# VSS nfet_06v0 ad=13p pd=50.52u as=13p ps=50.52u w=50u l=0.7u
X266 PULLUP_N_BLEED_1 PULLUP_N_BLEED_2 VSS ppolyf_u_1k r_width=1u r_length=12.5u
X267 a_41684_148611# a_41684_148611# a_41684_160275# VSS nfet_06v0 ad=13p pd=50.52u as=13p ps=50.52u w=50u l=0.7u
X268 ESD_RAIL a_42245_90628# VSS VSS nfet_06v0 ad=13p pd=50.52u as=13p ps=50.52u w=50u l=0.7u
X269 a_41684_148611# ESD_RAIL ESD_RAIL VSS nfet_06v0 ad=13p pd=50.52u as=13p ps=50.52u w=50u l=0.7u
X270 FS_N_BLEED_6 FS_N_GATE VSS ppolyf_u_1k r_width=1u r_length=12.5u
X271 a_41684_160275# a_41684_148611# a_41684_148611# VSS nfet_06v0 ad=13p pd=50.52u as=13p ps=50.52u w=50u l=0.7u
X272 a_41684_160275# a_41684_148611# a_41684_148611# VSS nfet_06v0 ad=13p pd=50.52u as=13p ps=50.52u w=50u l=0.7u
X273 a_41684_148611# a_41684_148611# a_41684_160275# VSS nfet_06v0 ad=13p pd=50.52u as=13p ps=50.52u w=50u l=0.7u
X274 HS_P_11 HS_PBIAS VDD VDD pfet_03v3 ad=8.8p pd=40.88u as=8.8p ps=40.88u w=20u l=1u
X275 a_41684_160275# a_41684_148611# a_41684_148611# VSS nfet_06v0 ad=13p pd=50.52u as=13p ps=50.52u w=50u l=0.7u
X276 a_41684_160275# a_41684_148611# a_41684_148611# VSS nfet_06v0 ad=13p pd=50.52u as=13p ps=50.52u w=50u l=0.7u
X277 a_41684_148611# a_41684_148611# a_41684_160275# VSS nfet_06v0 ad=13p pd=50.52u as=13p ps=50.52u w=50u l=0.7u
X278 a_41684_160275# a_41684_148611# a_41684_148611# VSS nfet_06v0 ad=13p pd=50.52u as=13p ps=50.52u w=50u l=0.7u
X279 a_41684_160275# a_41684_148611# a_41684_148611# VSS nfet_06v0 ad=13p pd=50.52u as=13p ps=50.52u w=50u l=0.7u
X280 ESD_RAIL ESD_RAIL a_41684_148611# VSS nfet_06v0 ad=13p pd=50.52u as=13p ps=50.52u w=50u l=0.7u
X281 a_41684_160275# a_41684_148611# a_41684_148611# VSS nfet_06v0 ad=13p pd=50.52u as=13p ps=50.52u w=50u l=0.7u
X282 VSS a_42245_90628# ESD_RAIL VSS nfet_06v0 ad=13p pd=50.52u as=13p ps=50.52u w=50u l=0.7u
X283 ESD_RAIL a_42245_90628# VSS VSS nfet_06v0 ad=13p pd=50.52u as=13p ps=50.52u w=50u l=0.7u
X284 FS_P_OUT FS_P_GATE FS_P_WELL FS_P_WELL pfet_03v3 ad=6.16p pd=28.88u as=6.16p ps=28.88u w=14u l=0.28u
X285 a_41684_148611# a_41684_148611# a_41684_160275# VSS nfet_06v0 ad=13p pd=50.52u as=13p ps=50.52u w=50u l=0.7u
X286 FS_N_OUT FS_N_GATE FS_N_WELL FS_N_WELL pfet_03v3 ad=6.16p pd=28.88u as=6.16p ps=28.88u w=14u l=0.28u
X287 VSS a_41684_160275# a_41684_160275# VSS nfet_06v0 ad=13p pd=50.52u as=13p ps=50.52u w=50u l=0.7u
X288 PULLUP_P_OUT PAD_P VSS ppolyf_u_1k r_width=1u r_length=1.18u
X289 a_41684_148611# a_41684_148611# a_41684_160275# VSS nfet_06v0 ad=13p pd=50.52u as=13p ps=50.52u w=50u l=0.7u
X290 FS_P_OUT FS_P_GATE FS_P_WELL FS_P_WELL pfet_03v3 ad=6.16p pd=28.88u as=6.16p ps=28.88u w=14u l=0.28u
X291 FS_N_OUT FS_N_GATE FS_N_WELL FS_N_WELL pfet_03v3 ad=6.16p pd=28.88u as=6.16p ps=28.88u w=14u l=0.28u
X292 a_41684_160275# a_41684_148611# a_41684_148611# VSS nfet_06v0 ad=13p pd=50.52u as=13p ps=50.52u w=50u l=0.7u
X293 VSS a_41684_160275# a_41684_160275# VSS nfet_06v0 ad=13p pd=50.52u as=13p ps=50.52u w=50u l=0.7u
X294 a_41684_160275# a_41684_160275# VSS VSS nfet_06v0 ad=13p pd=50.52u as=13p ps=50.52u w=50u l=0.7u
X295 VSS a_41684_160275# a_41684_160275# VSS nfet_06v0 ad=13p pd=50.52u as=13p ps=50.52u w=50u l=0.7u
X296 FS_P_OUT FS_P_GATE FS_P_WELL FS_P_WELL pfet_03v3 ad=6.16p pd=28.88u as=6.16p ps=28.88u w=14u l=0.28u
X297 VSS a_41684_160275# a_41684_160275# VSS nfet_06v0 ad=13p pd=50.52u as=13p ps=50.52u w=50u l=0.7u
X298 a_41684_148611# a_41684_148611# a_41684_160275# VSS nfet_06v0 ad=13p pd=50.52u as=13p ps=50.52u w=50u l=0.7u
X299 HS_P_3 HS_PBIAS VDD VDD pfet_03v3 ad=8.8p pd=40.88u as=8.8p ps=40.88u w=20u l=1u
X300 a_41684_148611# ESD_RAIL ESD_RAIL VSS nfet_06v0 ad=13p pd=50.52u as=13p ps=50.52u w=50u l=0.7u
X301 FS_N_BLEED_0 FS_N_BLEED_1 VSS ppolyf_u_1k r_width=1u r_length=12.5u
X302 TERM_OR_N_NS VCM_LOW_OK VSS VSS nfet_03v3 ad=1.76p pd=8.88u as=1.76p ps=8.88u w=4u l=0.28u
X303 a_41684_160275# a_41684_148611# a_41684_148611# VSS nfet_06v0 ad=13p pd=50.52u as=13p ps=50.52u w=50u l=0.7u
D6 VSS PULLUP_P diode_nd2ps_03v3 pj=6.2u area=2.4025p
X304 VSS a_41684_160275# a_41684_160275# VSS nfet_06v0 ad=13p pd=50.52u as=13p ps=50.52u w=50u l=0.7u
X305 ESD_RAIL a_42245_90628# VSS VSS nfet_06v0 ad=13p pd=50.52u as=13p ps=50.52u w=50u l=0.7u
X306 a_41684_160275# a_41684_148611# a_41684_148611# VSS nfet_06v0 ad=13p pd=50.52u as=13p ps=50.52u w=50u l=0.7u
X307 VSS a_41684_160275# a_41684_160275# VSS nfet_06v0 ad=13p pd=50.52u as=13p ps=50.52u w=50u l=0.7u
X308 a_41684_148611# a_41684_148611# a_41684_160275# VSS nfet_06v0 ad=13p pd=50.52u as=13p ps=50.52u w=50u l=0.7u
X309 a_41684_160275# a_41684_160275# VSS VSS nfet_06v0 ad=13p pd=50.52u as=13p ps=50.52u w=50u l=0.7u
X310 a_41684_160275# a_41684_160275# VSS VSS nfet_06v0 ad=13p pd=50.52u as=13p ps=50.52u w=50u l=0.7u
X311 FS_P_OUT FS_P_GATE FS_P_WELL FS_P_WELL pfet_03v3 ad=6.16p pd=28.88u as=6.16p ps=28.88u w=14u l=0.28u
X312 VSS a_42245_90628# ESD_RAIL VSS nfet_06v0 ad=13p pd=50.52u as=13p ps=50.52u w=50u l=0.7u
X313 VSS a_41684_160275# a_41684_160275# VSS nfet_06v0 ad=13p pd=50.52u as=13p ps=50.52u w=50u l=0.7u
X314 a_41684_160275# a_41684_148611# a_41684_148611# VSS nfet_06v0 ad=13p pd=50.52u as=13p ps=50.52u w=50u l=0.7u
X315 VSS a_41684_160275# a_41684_160275# VSS nfet_06v0 ad=13p pd=50.52u as=13p ps=50.52u w=50u l=0.7u
X316 a_41684_148611# a_41684_148611# a_41684_160275# VSS nfet_06v0 ad=13p pd=50.52u as=13p ps=50.52u w=50u l=0.7u
X317 FS_P_OUT FS_P_GATE FS_P_WELL FS_P_WELL pfet_03v3 ad=6.16p pd=28.88u as=6.16p ps=28.88u w=14u l=0.28u
X318 a_41684_160275# a_41684_160275# VSS VSS nfet_06v0 ad=13p pd=50.52u as=13p ps=50.52u w=50u l=0.7u
X319 a_41684_160275# a_41684_160275# VSS VSS nfet_06v0 ad=13p pd=50.52u as=13p ps=50.52u w=50u l=0.7u
X320 FS_N_OUT FS_N_GATE FS_N_WELL FS_N_WELL pfet_03v3 ad=6.16p pd=28.88u as=6.16p ps=28.88u w=14u l=0.28u
X321 VDD PULLUP_N_GATE PULLUP_N_WELL PULLUP_N_WELL pfet_03v3 ad=8.8p pd=40.88u as=8.8p ps=40.88u w=20u l=0.28u
X322 VSS a_41684_160275# a_41684_160275# VSS nfet_06v0 ad=13p pd=50.52u as=13p ps=50.52u w=50u l=0.7u
X323 ESD_RAIL a_42245_90628# VSS VSS nfet_06v0 ad=13p pd=50.52u as=13p ps=50.52u w=50u l=0.7u
X324 a_41684_160275# a_41684_160275# VSS VSS nfet_06v0 ad=13p pd=50.52u as=13p ps=50.52u w=50u l=0.7u
X325 VSS a_41684_160275# a_41684_160275# VSS nfet_06v0 ad=13p pd=50.52u as=13p ps=50.52u w=50u l=0.7u
D7 VSS ESD_RAIL diode_nd2ps_06v0 pj=82u area=40p
X326 FS_N_OUT FS_N_GATE FS_N_WELL FS_N_WELL pfet_03v3 ad=6.16p pd=28.88u as=6.16p ps=28.88u w=14u l=0.28u
X327 VSS a_41684_160275# a_41684_160275# VSS nfet_06v0 ad=13p pd=50.52u as=13p ps=50.52u w=50u l=0.7u
X328 a_41684_160275# a_41684_160275# VSS VSS nfet_06v0 ad=13p pd=50.52u as=13p ps=50.52u w=50u l=0.7u
X329 a_44789_117064# a_43813_117064# VSS VSS nfet_06v0 ad=1.3p pd=5.52u as=2.2p ps=10.88u w=5u l=0.7u
X330 a_41684_148611# ESD_RAIL ESD_RAIL VSS nfet_06v0 ad=13p pd=50.52u as=13p ps=50.52u w=50u l=0.7u
X331 a_41684_160275# a_41684_160275# VSS VSS nfet_06v0 ad=13p pd=50.52u as=13p ps=50.52u w=50u l=0.7u
X332 VSS a_41684_160275# a_41684_160275# VSS nfet_06v0 ad=22p pd=0.10088m as=13p ps=50.52u w=50u l=0.7u
X333 a_41684_148611# a_41684_148611# a_41684_160275# VSS nfet_06v0 ad=13p pd=50.52u as=13p ps=50.52u w=50u l=0.7u
X334 VSS a_42245_90628# ESD_RAIL VSS nfet_06v0 ad=13p pd=50.52u as=13p ps=50.52u w=50u l=0.7u
X335 a_41684_160275# a_41684_148611# a_41684_148611# VSS nfet_06v0 ad=13p pd=50.52u as=13p ps=50.52u w=50u l=0.7u
X336 HS_P_13 HS_PBIAS VDD VDD pfet_03v3 ad=8.8p pd=40.88u as=8.8p ps=40.88u w=20u l=1u
X337 a_41684_148611# ESD_RAIL ESD_RAIL VSS nfet_06v0 ad=13p pd=50.52u as=13p ps=50.52u w=50u l=0.7u
D8 VSS ESD_RAIL diode_nd2ps_06v0 pj=82u area=40p
X338 VSS a_41684_160275# a_41684_160275# VSS nfet_06v0 ad=13p pd=50.52u as=13p ps=50.52u w=50u l=0.7u
X339 VSS a_41684_160275# a_41684_160275# VSS nfet_06v0 ad=13p pd=50.52u as=13p ps=50.52u w=50u l=0.7u
X340 a_41684_148611# ESD_RAIL ESD_RAIL VSS nfet_06v0 ad=13p pd=50.52u as=13p ps=50.52u w=50u l=0.7u
X341 ESD_RAIL ESD_RAIL a_41684_148611# VSS nfet_06v0 ad=13p pd=50.52u as=13p ps=50.52u w=50u l=0.7u
X342 a_41684_148611# ESD_RAIL ESD_RAIL VSS nfet_06v0 ad=13p pd=50.52u as=13p ps=50.52u w=50u l=0.7u
X343 TERM_P_R DIFF_ENABLE TERM_N_R VSS nfet_03v3 ad=8.8p pd=40.88u as=8.8p ps=40.88u w=20u l=0.28u
X344 a_41684_160275# a_41684_160275# VSS VSS nfet_06v0 ad=13p pd=50.52u as=13p ps=50.52u w=50u l=0.7u
X345 PAD_N DIV_N VSS ppolyf_u_1k r_width=1u r_length=2u
X346 VSS a_41684_160275# a_41684_160275# VSS nfet_06v0 ad=13p pd=50.52u as=13p ps=50.52u w=50u l=0.7u
X347 a_41684_160275# a_41684_160275# VSS VSS nfet_06v0 ad=13p pd=50.52u as=13p ps=50.52u w=50u l=0.7u
X348 TERM_GATE_N_BLEED_1 TERM_GATE_N_BLEED_2 VSS ppolyf_u_1k r_width=1u r_length=12.5u
X349 VSS a_41684_160275# a_41684_160275# VSS nfet_06v0 ad=13p pd=50.52u as=13p ps=50.52u w=50u l=0.7u
X350 a_41684_160275# a_41684_160275# VSS VSS nfet_06v0 ad=13p pd=50.52u as=13p ps=50.52u w=50u l=0.7u
X351 VSS a_41684_160275# a_41684_160275# VSS nfet_06v0 ad=13p pd=50.52u as=13p ps=50.52u w=50u l=0.7u
X352 a_41684_148611# ESD_RAIL ESD_RAIL VSS nfet_06v0 ad=13p pd=50.52u as=13p ps=50.52u w=50u l=0.7u
X353 a_41684_160275# a_41684_160275# VSS VSS nfet_06v0 ad=13p pd=50.52u as=13p ps=50.52u w=50u l=0.7u
X354 a_41684_160275# a_41684_148611# a_41684_148611# VSS nfet_06v0 ad=13p pd=50.52u as=13p ps=50.52u w=50u l=0.7u
X355 a_41684_148611# ESD_RAIL ESD_RAIL VSS nfet_06v0 ad=13p pd=50.52u as=13p ps=50.52u w=50u l=0.7u
X356 PULLUP_P_BLEED_4 PULLUP_P_BLEED_5 VSS ppolyf_u_1k r_width=1u r_length=12.5u
X357 VSS a_41684_160275# a_41684_160275# VSS nfet_06v0 ad=13p pd=50.52u as=13p ps=50.52u w=50u l=0.7u
X358 a_41684_148611# a_41684_148611# a_41684_160275# VSS nfet_06v0 ad=13p pd=50.52u as=13p ps=50.52u w=50u l=0.7u
X359 FS_N_OUT FS_N_GATE FS_N_WELL FS_N_WELL pfet_03v3 ad=6.16p pd=28.88u as=6.16p ps=28.88u w=14u l=0.28u
X360 a_41684_160275# a_41684_160275# VSS VSS nfet_06v0 ad=13p pd=50.52u as=13p ps=50.52u w=50u l=0.7u
X361 ESD_RAIL ESD_RAIL a_41684_148611# VSS nfet_06v0 ad=13p pd=50.52u as=13p ps=50.52u w=50u l=0.7u
X362 ESD_RAIL a_42245_90628# VSS VSS nfet_06v0 ad=13p pd=50.52u as=13p ps=50.52u w=50u l=0.7u
X363 ESD_RAIL ESD_RAIL a_41684_148611# VSS nfet_06v0 ad=13p pd=50.52u as=13p ps=50.52u w=50u l=0.7u
X364 FS_N_OUT FS_N_GATE FS_N_WELL FS_N_WELL pfet_03v3 ad=6.16p pd=28.88u as=6.16p ps=28.88u w=14u l=0.28u
X365 FS_P_OUT FS_P_GATE FS_P_WELL FS_P_WELL pfet_03v3 ad=6.16p pd=28.88u as=6.16p ps=28.88u w=14u l=0.28u
X366 VSS a_41684_160275# a_41684_160275# VSS nfet_06v0 ad=13p pd=50.52u as=13p ps=50.52u w=50u l=0.7u
X367 a_41684_148611# ESD_RAIL ESD_RAIL VSS nfet_06v0 ad=13p pd=50.52u as=13p ps=50.52u w=50u l=0.7u
X368 ESD_RAIL ESD_RAIL a_41684_148611# VSS nfet_06v0 ad=13p pd=50.52u as=13p ps=50.52u w=50u l=0.7u
X369 a_41684_148611# ESD_RAIL ESD_RAIL VSS nfet_06v0 ad=13p pd=50.52u as=13p ps=50.52u w=50u l=0.7u
X370 FS_N_CONTROL_S VDD VSS VSS nfet_03v3 ad=1.76p pd=8.88u as=1.76p ps=8.88u w=4u l=0.28u
X371 FS_N_OUT FS_N_GATE FS_N_WELL FS_N_WELL pfet_03v3 ad=6.16p pd=28.88u as=6.16p ps=28.88u w=14u l=0.28u
X372 a_41684_160275# a_41684_160275# VSS VSS nfet_06v0 ad=13p pd=50.52u as=13p ps=50.52u w=50u l=0.7u
X373 a_41684_160275# a_41684_160275# VSS VSS nfet_06v0 ad=13p pd=50.52u as=13p ps=50.52u w=50u l=0.7u
X374 ESD_RAIL ESD_RAIL a_41684_148611# VSS nfet_06v0 ad=13p pd=50.52u as=13p ps=50.52u w=50u l=0.7u
X375 a_41005_131825# a_53878_131545# ESD_RAIL ppolyf_u r_width=0.8u r_length=63.855u
X376 PULLUP_N_BLEED_5 PULLUP_N_BLEED_6 VSS ppolyf_u_1k r_width=1u r_length=12.5u
X377 VSS a_41684_160275# a_41684_160275# VSS nfet_06v0 ad=13p pd=50.52u as=13p ps=50.52u w=50u l=0.7u
X378 a_41684_148611# ESD_RAIL ESD_RAIL VSS nfet_06v0 ad=13p pd=50.52u as=13p ps=50.52u w=50u l=0.7u
X379 a_41684_148611# ESD_RAIL ESD_RAIL VSS nfet_06v0 ad=13p pd=50.52u as=13p ps=50.52u w=50u l=0.7u
X380 ESD_RAIL ESD_RAIL a_41684_148611# VSS nfet_06v0 ad=13p pd=50.52u as=13p ps=50.52u w=50u l=0.7u
X381 a_41684_160275# a_41684_160275# VSS VSS nfet_06v0 ad=13p pd=50.52u as=13p ps=50.52u w=50u l=0.7u
X382 a_41684_160275# a_41684_160275# VSS VSS nfet_06v0 ad=13p pd=50.52u as=13p ps=50.52u w=50u l=0.7u
X383 VSS a_41684_160275# a_41684_160275# VSS nfet_06v0 ad=13p pd=50.52u as=13p ps=50.52u w=50u l=0.7u
X384 ESD_RAIL ESD_RAIL a_41684_148611# VSS nfet_06v0 ad=13p pd=50.52u as=13p ps=50.52u w=50u l=0.7u
X385 a_41684_148611# ESD_RAIL ESD_RAIL VSS nfet_06v0 ad=13p pd=50.52u as=13p ps=50.52u w=50u l=0.7u
X386 a_41684_160275# a_41684_160275# VSS VSS nfet_06v0 ad=13p pd=50.52u as=13p ps=50.52u w=50u l=0.7u
X387 a_41684_148611# ESD_RAIL ESD_RAIL VSS nfet_06v0 ad=22p pd=0.10088m as=13p ps=50.52u w=50u l=0.7u
X388 ESD_RAIL ESD_RAIL a_41684_148611# VSS nfet_06v0 ad=13p pd=50.52u as=13p ps=50.52u w=50u l=0.7u
X389 PULLUP_P_GATE PULLUP_P PULLUP_P_CONTROL_S VSS nfet_06v0 ad=0.88p pd=4.88u as=0.88p ps=4.88u w=2u l=0.7u
X390 VSS a_41684_160275# a_41684_160275# VSS nfet_06v0 ad=13p pd=50.52u as=13p ps=50.52u w=50u l=0.7u
X391 a_41684_148611# ESD_RAIL ESD_RAIL VSS nfet_06v0 ad=13p pd=50.52u as=13p ps=50.52u w=50u l=0.7u
X392 VCM_LOW_OK TERM_VCM VSS VSS nfet_03v3 ad=3.52p pd=16.88u as=3.52p ps=16.88u w=8u l=0.28u
X393 TERM_OR_P_B VCM_LOW_OK TERM_OR_P_S VDD pfet_03v3 ad=1.76p pd=8.88u as=1.76p ps=8.88u w=4u l=0.28u
X394 a_41684_148611# ESD_RAIL ESD_RAIL VSS nfet_06v0 ad=13p pd=50.52u as=13p ps=50.52u w=50u l=0.7u
X395 a_41684_160275# a_41684_160275# VSS VSS nfet_06v0 ad=13p pd=50.52u as=13p ps=50.52u w=50u l=0.7u
X396 ESD_RAIL ESD_RAIL a_41684_148611# VSS nfet_06v0 ad=13p pd=50.52u as=13p ps=50.52u w=50u l=0.7u
X397 VSS a_41684_160275# a_41684_160275# VSS nfet_06v0 ad=13p pd=50.52u as=13p ps=50.52u w=50u l=0.7u
X398 a_41684_148611# ESD_RAIL ESD_RAIL VSS nfet_06v0 ad=13p pd=50.52u as=13p ps=50.52u w=50u l=0.7u
X399 ESD_RAIL ESD_RAIL a_41684_148611# VSS nfet_06v0 ad=13p pd=50.52u as=13p ps=50.52u w=50u l=0.7u
X400 a_41684_148611# ESD_RAIL ESD_RAIL VSS nfet_06v0 ad=13p pd=50.52u as=13p ps=50.52u w=50u l=0.7u
X401 VSS a_41684_160275# a_41684_160275# VSS nfet_06v0 ad=13p pd=50.52u as=13p ps=50.52u w=50u l=0.7u
X402 TERM_GATE_P_BLEED_2 VSS VSS ppolyf_u_1k r_width=1u r_length=12.5u
X403 a_41684_148611# ESD_RAIL ESD_RAIL VSS nfet_06v0 ad=13p pd=50.52u as=13p ps=50.52u w=50u l=0.7u
X404 ESD_RAIL ESD_RAIL a_41684_148611# VSS nfet_06v0 ad=13p pd=50.52u as=13p ps=50.52u w=50u l=0.7u
X405 FS_N_OUT FS_N_GATE FS_N_WELL FS_N_WELL pfet_03v3 ad=6.16p pd=28.88u as=6.16p ps=28.88u w=14u l=0.28u
X406 a_41684_160275# a_41684_160275# VSS VSS nfet_06v0 ad=13p pd=50.52u as=13p ps=50.52u w=50u l=0.7u
X407 a_41684_160275# a_41684_148611# a_41684_148611# VSS nfet_06v0 ad=13p pd=50.52u as=13p ps=50.52u w=50u l=0.7u
X408 ESD_RAIL ESD_RAIL a_41684_148611# VSS nfet_06v0 ad=13p pd=50.52u as=13p ps=50.52u w=50u l=0.7u
X409 a_41684_148611# ESD_RAIL ESD_RAIL VSS nfet_06v0 ad=13p pd=50.52u as=13p ps=50.52u w=50u l=0.7u
X410 VSS a_41684_160275# a_41684_160275# VSS nfet_06v0 ad=13p pd=50.52u as=13p ps=50.52u w=50u l=0.7u
X411 VSS a_41684_160275# a_41684_160275# VSS nfet_06v0 ad=13p pd=50.52u as=13p ps=50.52u w=50u l=0.7u
X412 ESD_RAIL ESD_RAIL a_41684_148611# VSS nfet_06v0 ad=13p pd=50.52u as=13p ps=50.52u w=50u l=0.7u
X413 HS_N_11 HS_PBIAS VDD VDD pfet_03v3 ad=8.8p pd=40.88u as=8.8p ps=40.88u w=20u l=1u
D9 VSS FS_LOW_N diode_nd2ps_03v3 pj=2.4u area=0.36p
X414 VSS a_41684_160275# a_41684_160275# VSS nfet_06v0 ad=13p pd=50.52u as=13p ps=50.52u w=50u l=0.7u
X415 a_41684_148611# ESD_RAIL ESD_RAIL VSS nfet_06v0 ad=13p pd=50.52u as=13p ps=50.52u w=50u l=0.7u
X416 ESD_RAIL ESD_RAIL a_41684_148611# VSS nfet_06v0 ad=13p pd=50.52u as=13p ps=50.52u w=50u l=0.7u
X417 VSS a_42245_90628# ESD_RAIL VSS nfet_06v0 ad=13p pd=50.52u as=13p ps=50.52u w=50u l=0.7u
X418 ESD_RAIL ESD_RAIL a_41684_148611# VSS nfet_06v0 ad=13p pd=50.52u as=13p ps=50.52u w=50u l=0.7u
X419 a_41684_148611# a_41684_148611# a_41684_160275# VSS nfet_06v0 ad=13p pd=50.52u as=13p ps=50.52u w=50u l=0.7u
X420 ESD_RAIL a_44789_117064# a_42245_90628# ESD_RAIL pfet_06v0 ad=1.3p pd=5.52u as=1.3p ps=5.52u w=5u l=0.7u
X421 VSS a_41684_160275# a_41684_160275# VSS nfet_06v0 ad=13p pd=50.52u as=13p ps=50.52u w=50u l=0.7u
X422 a_41684_148611# ESD_RAIL ESD_RAIL VSS nfet_06v0 ad=13p pd=50.52u as=13p ps=50.52u w=50u l=0.7u
X423 a_41005_132945# a_53878_132665# ESD_RAIL ppolyf_u r_width=0.8u r_length=63.855u
X424 ESD_RAIL ESD_RAIL a_41684_148611# VSS nfet_06v0 ad=13p pd=50.52u as=13p ps=50.52u w=50u l=0.7u
D10 VSS PAD_P diode_nd2ps_06v0 pj=51.8u area=22.5p
X425 HS_P_10 HS_P PAD_P VSS nfet_06v0 ad=8.8p pd=40.88u as=8.8p ps=40.88u w=20u l=0.7u
X426 ESD_RAIL ESD_RAIL a_41684_148611# VSS nfet_06v0 ad=13p pd=50.52u as=13p ps=50.52u w=50u l=0.7u
X427 FS_N_OUT FS_N_GATE FS_N_WELL FS_N_WELL pfet_03v3 ad=6.16p pd=28.88u as=6.16p ps=28.88u w=14u l=0.28u
X428 a_41684_148611# a_41684_148611# a_41684_160275# VSS nfet_06v0 ad=13p pd=50.52u as=13p ps=50.52u w=50u l=0.7u
X429 a_41684_148611# ESD_RAIL ESD_RAIL VSS nfet_06v0 ad=13p pd=50.52u as=13p ps=50.52u w=50u l=0.7u
X430 PAD_N PULLDOWN_N_R VSS ppolyf_u_1k r_width=1u r_length=14.2u
X431 TERM_P_R TERM_GATE_P TERM_VCM VSS nfet_03v3 ad=8.8p pd=40.88u as=8.8p ps=40.88u w=20u l=0.28u
X432 ESD_RAIL a_42245_90628# VSS VSS nfet_06v0 ad=13p pd=50.52u as=13p ps=50.52u w=50u l=0.7u
X433 PAD_P BYPASS_ENABLE RX_P VSS nfet_06v0 ad=8.8p pd=40.88u as=8.8p ps=40.88u w=20u l=0.7u
X434 ESD_RAIL ESD_RAIL a_41684_148611# VSS nfet_06v0 ad=13p pd=50.52u as=13p ps=50.52u w=50u l=0.7u
X435 FS_N_OUT FS_N_GATE FS_N_WELL FS_N_WELL pfet_03v3 ad=6.16p pd=28.88u as=6.16p ps=28.88u w=14u l=0.28u
X436 a_41684_160275# a_41684_148611# a_41684_148611# VSS nfet_06v0 ad=13p pd=50.52u as=13p ps=50.52u w=50u l=0.7u
X437 a_41684_148611# a_41684_148611# a_41684_160275# VSS nfet_06v0 ad=13p pd=50.52u as=13p ps=50.52u w=50u l=0.7u
X438 HS_P_5 HS_P PAD_P VSS nfet_06v0 ad=8.8p pd=40.88u as=8.8p ps=40.88u w=20u l=0.7u
X439 a_41684_148611# ESD_RAIL ESD_RAIL VSS nfet_06v0 ad=13p pd=50.52u as=13p ps=50.52u w=50u l=0.7u
X440 a_41684_160275# a_41684_148611# a_41684_148611# VSS nfet_06v0 ad=13p pd=50.52u as=13p ps=50.52u w=50u l=0.7u
X441 a_41684_148611# a_41684_148611# a_41684_160275# VSS nfet_06v0 ad=13p pd=50.52u as=13p ps=50.52u w=50u l=0.7u
X442 ESD_RAIL ESD_RAIL a_41684_148611# VSS nfet_06v0 ad=13p pd=50.52u as=13p ps=50.52u w=50u l=0.7u
X443 VSS a_42245_90628# ESD_RAIL VSS nfet_06v0 ad=13p pd=50.52u as=13p ps=50.52u w=50u l=0.7u
X444 a_41684_160275# a_41684_160275# VSS VSS nfet_06v0 ad=13p pd=50.52u as=13p ps=50.52u w=50u l=0.7u
X445 a_41684_148611# ESD_RAIL ESD_RAIL VSS nfet_06v0 ad=13p pd=50.52u as=13p ps=50.52u w=50u l=0.7u
X446 DIV_P DIV_ENABLE RX_P VSS nfet_06v0 ad=8.8p pd=40.88u as=8.8p ps=40.88u w=20u l=0.7u
X447 a_41684_148611# ESD_RAIL ESD_RAIL VSS nfet_06v0 ad=13p pd=50.52u as=13p ps=50.52u w=50u l=0.7u
X448 VSS a_42245_90628# ESD_RAIL VSS nfet_06v0 ad=13p pd=50.52u as=13p ps=50.52u w=50u l=0.7u
X449 a_41684_160275# a_41684_148611# a_41684_148611# VSS nfet_06v0 ad=13p pd=50.52u as=13p ps=50.52u w=50u l=0.7u
X450 VSS a_41684_160275# a_41684_160275# VSS nfet_06v0 ad=13p pd=50.52u as=13p ps=50.52u w=50u l=0.7u
X451 ESD_RAIL ESD_RAIL a_41684_148611# VSS nfet_06v0 ad=13p pd=50.52u as=13p ps=50.52u w=50u l=0.7u
X452 HS_P_6 HS_P PAD_P VSS nfet_06v0 ad=8.8p pd=40.88u as=8.8p ps=40.88u w=20u l=0.7u
X453 a_41684_148611# ESD_RAIL ESD_RAIL VSS nfet_06v0 ad=13p pd=50.52u as=13p ps=50.52u w=50u l=0.7u
X454 FS_N_OUT FS_N_GATE FS_N_WELL FS_N_WELL pfet_03v3 ad=6.16p pd=28.88u as=6.16p ps=28.88u w=14u l=0.28u
X455 a_41684_160275# a_41684_160275# VSS VSS nfet_06v0 ad=13p pd=50.52u as=13p ps=50.52u w=50u l=0.7u
X456 a_41684_148611# ESD_RAIL ESD_RAIL VSS nfet_06v0 ad=13p pd=50.52u as=13p ps=50.52u w=50u l=0.7u
X457 ESD_RAIL a_42245_90628# VSS VSS nfet_06v0 ad=13p pd=50.52u as=13p ps=50.52u w=50u l=0.7u
X458 a_41684_160275# a_41684_148611# a_41684_148611# VSS nfet_06v0 ad=13p pd=50.52u as=13p ps=50.52u w=50u l=0.7u
X459 VSS a_41684_160275# a_41684_160275# VSS nfet_06v0 ad=13p pd=50.52u as=13p ps=50.52u w=50u l=0.7u
X460 a_41684_148611# a_41684_148611# a_41684_160275# VSS nfet_06v0 ad=13p pd=50.52u as=13p ps=50.52u w=50u l=0.7u
X461 a_41684_148611# ESD_RAIL ESD_RAIL VSS nfet_06v0 ad=13p pd=50.52u as=13p ps=50.52u w=50u l=0.7u
X462 a_41684_160275# a_41684_148611# a_41684_148611# VSS nfet_06v0 ad=13p pd=50.52u as=13p ps=50.52u w=50u l=0.7u
X463 a_42245_90628# a_44789_117064# ESD_RAIL ESD_RAIL pfet_06v0 ad=1.3p pd=5.52u as=1.3p ps=5.52u w=5u l=0.7u
X464 a_43813_117064# a_41005_131545# ESD_RAIL ESD_RAIL pfet_06v0 ad=1.3p pd=5.52u as=1.3p ps=5.52u w=5u l=0.7u
X465 FS_N_OUT FS_N_GATE FS_N_WELL FS_N_WELL pfet_03v3 ad=6.16p pd=28.88u as=6.16p ps=28.88u w=14u l=0.28u
X466 a_41684_148611# a_41684_148611# a_41684_160275# VSS nfet_06v0 ad=13p pd=50.52u as=13p ps=50.52u w=50u l=0.7u
X467 a_41684_148611# ESD_RAIL ESD_RAIL VSS nfet_06v0 ad=13p pd=50.52u as=13p ps=50.52u w=50u l=0.7u
X468 VSS a_41684_160275# a_41684_160275# VSS nfet_06v0 ad=13p pd=50.52u as=13p ps=50.52u w=50u l=0.7u
X469 a_41684_148611# a_41684_148611# a_41684_160275# VSS nfet_06v0 ad=13p pd=50.52u as=13p ps=50.52u w=50u l=0.7u
X470 a_41684_160275# a_41684_160275# VSS VSS nfet_06v0 ad=13p pd=50.52u as=13p ps=50.52u w=50u l=0.7u
X471 VDD PULLUP_N_GATE PULLUP_N_WELL PULLUP_N_WELL pfet_03v3 ad=8.8p pd=40.88u as=8.8p ps=40.88u w=20u l=0.28u
X472 a_41684_160275# a_41684_160275# VSS VSS nfet_06v0 ad=13p pd=50.52u as=13p ps=50.52u w=50u l=0.7u
X473 VSS a_41684_160275# a_41684_160275# VSS nfet_06v0 ad=13p pd=50.52u as=13p ps=50.52u w=50u l=0.7u
X474 VSS a_41684_160275# a_41684_160275# VSS nfet_06v0 ad=13p pd=50.52u as=13p ps=50.52u w=50u l=0.7u
X475 TERM_P_R TERM_GATE_P TERM_VCM VSS nfet_03v3 ad=8.8p pd=40.88u as=8.8p ps=40.88u w=20u l=0.28u
X476 a_41684_148611# a_41684_148611# a_41684_160275# VSS nfet_06v0 ad=13p pd=50.52u as=13p ps=50.52u w=50u l=0.7u
X477 a_41684_160275# a_41684_160275# VSS VSS nfet_06v0 ad=13p pd=50.52u as=22p ps=0.10088m w=50u l=0.7u
X478 a_41684_160275# a_41684_148611# a_41684_148611# VSS nfet_06v0 ad=13p pd=50.52u as=13p ps=50.52u w=50u l=0.7u
X479 a_44789_117064# a_43813_117064# ESD_RAIL ESD_RAIL pfet_06v0 ad=2.2p pd=10.88u as=1.3p ps=5.52u w=5u l=0.7u
X480 HS_P_3 HS_P PAD_P VSS nfet_06v0 ad=8.8p pd=40.88u as=8.8p ps=40.88u w=20u l=0.7u
X481 FS_P_WELL FS_P_BLEED_0 VSS ppolyf_u_1k r_width=1u r_length=12.5u
X482 ESD_RAIL ESD_RAIL a_41684_148611# VSS nfet_06v0 ad=13p pd=50.52u as=13p ps=50.52u w=50u l=0.7u
X483 VDD FS_P_GATE FS_P_WELL FS_P_WELL pfet_03v3 ad=6.16p pd=28.88u as=6.16p ps=28.88u w=14u l=0.28u
X484 a_41684_160275# a_41684_148611# a_41684_148611# VSS nfet_06v0 ad=13p pd=50.52u as=13p ps=50.52u w=50u l=0.7u
X485 a_41684_148611# a_41684_148611# a_41684_160275# VSS nfet_06v0 ad=13p pd=50.52u as=13p ps=50.52u w=50u l=0.7u
D11 VSS PAD_N diode_nd2ps_06v0 pj=51.8u area=22.5p
X486 ESD_RAIL a_42245_90628# VSS VSS nfet_06v0 ad=13p pd=50.52u as=13p ps=50.52u w=50u l=0.7u
X487 VSS a_41684_160275# a_41684_160275# VSS nfet_06v0 ad=13p pd=50.52u as=13p ps=50.52u w=50u l=0.7u
X488 a_41684_160275# a_41684_148611# a_41684_148611# VSS nfet_06v0 ad=13p pd=50.52u as=13p ps=50.52u w=50u l=0.7u
X489 a_41684_148611# ESD_RAIL ESD_RAIL VSS nfet_06v0 ad=13p pd=50.52u as=13p ps=50.52u w=50u l=0.7u
X490 a_41684_160275# a_41684_160275# VSS VSS nfet_06v0 ad=13p pd=50.52u as=13p ps=50.52u w=50u l=0.7u
X491 a_41684_160275# a_41684_160275# VSS VSS nfet_06v0 ad=13p pd=50.52u as=13p ps=50.52u w=50u l=0.7u
X492 ESD_RAIL ESD_RAIL a_41684_148611# VSS nfet_06v0 ad=13p pd=50.52u as=13p ps=50.52u w=50u l=0.7u
X493 a_41684_160275# a_41684_148611# a_41684_148611# VSS nfet_06v0 ad=13p pd=50.52u as=13p ps=50.52u w=50u l=0.7u
X494 FS_P_BLEED_1 FS_P_BLEED_2 VSS ppolyf_u_1k r_width=1u r_length=12.5u
X495 VSS a_41684_160275# a_41684_160275# VSS nfet_06v0 ad=13p pd=50.52u as=13p ps=50.52u w=50u l=0.7u
X496 a_41684_148611# ESD_RAIL ESD_RAIL VSS nfet_06v0 ad=13p pd=50.52u as=13p ps=50.52u w=50u l=0.7u
X497 VDD FS_P_GATE FS_P_WELL FS_P_WELL pfet_03v3 ad=6.16p pd=28.88u as=6.16p ps=28.88u w=14u l=0.28u
X498 a_41684_160275# a_41684_160275# VSS VSS nfet_06v0 ad=13p pd=50.52u as=13p ps=50.52u w=50u l=0.7u
X499 PULLUP_P_OUT PULLUP_P_GATE PULLUP_P_WELL PULLUP_P_WELL pfet_03v3 ad=8.8p pd=40.88u as=8.8p ps=40.88u w=20u l=0.28u
X500 VSS a_42245_90628# ESD_RAIL VSS nfet_06v0 ad=13p pd=50.52u as=13p ps=50.52u w=50u l=0.7u
X501 a_41684_160275# a_41684_148611# a_41684_148611# VSS nfet_06v0 ad=13p pd=50.52u as=13p ps=50.52u w=50u l=0.7u
X502 a_41684_148611# a_41684_148611# a_41684_160275# VSS nfet_06v0 ad=13p pd=50.52u as=13p ps=50.52u w=50u l=0.7u
X503 VSS ESD_RAIL VSS ppolyf_u_1k_6p0 r_width=1u r_length=9.98874m
X504 TERM_N_R TERM_GATE_N TERM_VCM VSS nfet_03v3 ad=8.8p pd=40.88u as=8.8p ps=40.88u w=20u l=0.28u
X505 a_41684_160275# a_41684_160275# VSS VSS nfet_06v0 ad=13p pd=50.52u as=13p ps=50.52u w=50u l=0.7u
X506 VSS a_41684_160275# a_41684_160275# VSS nfet_06v0 ad=13p pd=50.52u as=13p ps=50.52u w=50u l=0.7u
X507 HS_P_12 HS_P PAD_P VSS nfet_06v0 ad=8.8p pd=40.88u as=8.8p ps=40.88u w=20u l=0.7u
X508 a_41684_148611# ESD_RAIL ESD_RAIL VSS nfet_06v0 ad=13p pd=50.52u as=13p ps=50.52u w=50u l=0.7u
X509 FS_N_OUT FS_N_GATE FS_N_WELL FS_N_WELL pfet_03v3 ad=6.16p pd=28.88u as=6.16p ps=28.88u w=14u l=0.28u
X510 a_41684_148611# a_41684_148611# a_41684_160275# VSS nfet_06v0 ad=13p pd=50.52u as=13p ps=50.52u w=50u l=0.7u
X511 ESD_RAIL a_44789_117064# a_42245_90628# ESD_RAIL pfet_06v0 ad=2.2p pd=10.88u as=1.3p ps=5.52u w=5u l=0.7u
X512 a_42245_90628# a_44789_117064# ESD_RAIL ESD_RAIL pfet_06v0 ad=1.3p pd=5.52u as=1.3p ps=5.52u w=5u l=0.7u
X513 a_41684_160275# a_41684_160275# VSS VSS nfet_06v0 ad=13p pd=50.52u as=13p ps=50.52u w=50u l=0.7u
X514 a_41684_148611# a_41684_148611# a_41684_160275# VSS nfet_06v0 ad=13p pd=50.52u as=13p ps=50.52u w=50u l=0.7u
X515 ESD_RAIL ESD_RAIL a_41684_148611# VSS nfet_06v0 ad=13p pd=50.52u as=13p ps=50.52u w=50u l=0.7u
X516 VSS a_42245_90628# ESD_RAIL VSS nfet_06v0 ad=13p pd=50.52u as=13p ps=50.52u w=50u l=0.7u
X517 PAD_N TERM_N_R VSS ppolyf_u r_width=16u r_length=1.3u
X518 HS_N_1 HS_PBIAS VDD VDD pfet_03v3 ad=8.8p pd=40.88u as=8.8p ps=40.88u w=20u l=1u
X519 a_41684_148611# ESD_RAIL ESD_RAIL VSS nfet_06v0 ad=13p pd=50.52u as=13p ps=50.52u w=50u l=0.7u
X520 ESD_RAIL ESD_RAIL a_41684_148611# VSS nfet_06v0 ad=13p pd=50.52u as=13p ps=50.52u w=50u l=0.7u
X521 PULLUP_N_GATE PULLUP_N PULLUP_N_CONTROL_S VSS nfet_06v0 ad=0.88p pd=4.88u as=0.88p ps=4.88u w=2u l=0.7u
X522 VSS a_41684_160275# a_41684_160275# VSS nfet_06v0 ad=13p pd=50.52u as=13p ps=50.52u w=50u l=0.7u
X523 VSS a_41684_160275# a_41684_160275# VSS nfet_06v0 ad=13p pd=50.52u as=13p ps=50.52u w=50u l=0.7u
X524 a_41684_148611# a_41684_148611# a_41684_160275# VSS nfet_06v0 ad=13p pd=50.52u as=13p ps=50.52u w=50u l=0.7u
X525 a_41684_148611# ESD_RAIL ESD_RAIL VSS nfet_06v0 ad=13p pd=50.52u as=13p ps=50.52u w=50u l=0.7u
X526 a_41684_148611# a_41684_148611# a_41684_160275# VSS nfet_06v0 ad=13p pd=50.52u as=13p ps=50.52u w=50u l=0.7u
X527 a_41684_160275# a_41684_160275# VSS VSS nfet_06v0 ad=13p pd=50.52u as=13p ps=50.52u w=50u l=0.7u
X528 ESD_RAIL ESD_RAIL a_41684_148611# VSS nfet_06v0 ad=13p pd=50.52u as=22p ps=0.10088m w=50u l=0.7u
X529 FS_N_BLEED_1 FS_N_BLEED_2 VSS ppolyf_u_1k r_width=1u r_length=12.5u
X530 TERM_OR_N_B VCM_LOW_OK TERM_OR_N_S VDD pfet_03v3 ad=1.76p pd=8.88u as=1.76p ps=8.88u w=4u l=0.28u
X531 VSS a_41684_160275# a_41684_160275# VSS nfet_06v0 ad=13p pd=50.52u as=13p ps=50.52u w=50u l=0.7u
X532 a_41684_160275# a_41684_160275# VSS VSS nfet_06v0 ad=13p pd=50.52u as=13p ps=50.52u w=50u l=0.7u
X533 DIV_N DIV_ENABLE RX_N VSS nfet_06v0 ad=8.8p pd=40.88u as=8.8p ps=40.88u w=20u l=0.7u
X534 a_41005_134065# a_53878_133785# ESD_RAIL ppolyf_u r_width=0.8u r_length=63.855u
X535 a_41684_160275# a_41684_160275# VSS VSS nfet_06v0 ad=13p pd=50.52u as=13p ps=50.52u w=50u l=0.7u
X536 FS_P_GATE FS_HIGH_P FS_P_CONTROL_S VSS nfet_06v0 ad=0.88p pd=4.88u as=0.88p ps=4.88u w=2u l=0.7u
X537 VSS a_41684_160275# a_41684_160275# VSS nfet_06v0 ad=13p pd=50.52u as=13p ps=50.52u w=50u l=0.7u
X538 a_41684_148611# ESD_RAIL ESD_RAIL VSS nfet_06v0 ad=13p pd=50.52u as=13p ps=50.52u w=50u l=0.7u
X539 VDD FS_P_GATE FS_P_WELL FS_P_WELL pfet_03v3 ad=6.16p pd=28.88u as=6.16p ps=28.88u w=14u l=0.28u
X540 a_41684_160275# a_41684_160275# VSS VSS nfet_06v0 ad=13p pd=50.52u as=13p ps=50.52u w=50u l=0.7u
X541 HS_P_10 HS_PBIAS VDD VDD pfet_03v3 ad=8.8p pd=40.88u as=8.8p ps=40.88u w=20u l=1u
X542 ESD_RAIL ESD_RAIL a_41684_148611# VSS nfet_06v0 ad=13p pd=50.52u as=13p ps=50.52u w=50u l=0.7u
X543 a_41684_160275# a_41684_160275# VSS VSS nfet_06v0 ad=13p pd=50.52u as=13p ps=50.52u w=50u l=0.7u
X544 VSS a_42245_90628# ESD_RAIL VSS nfet_06v0 ad=13p pd=50.52u as=13p ps=50.52u w=50u l=0.7u
X545 ESD_RAIL ESD_RAIL a_41684_148611# VSS nfet_06v0 ad=13p pd=50.52u as=13p ps=50.52u w=50u l=0.7u
X546 VSS a_42245_90628# ESD_RAIL VSS nfet_06v0 ad=13p pd=50.52u as=13p ps=50.52u w=50u l=0.7u
X547 ESD_RAIL a_44789_117064# a_42245_90628# ESD_RAIL pfet_06v0 ad=1.3p pd=5.52u as=1.3p ps=5.52u w=5u l=0.7u
X548 TERM_N_R TERM_GATE_N TERM_VCM VSS nfet_03v3 ad=8.8p pd=40.88u as=8.8p ps=40.88u w=20u l=0.28u
X549 VSS a_41684_160275# a_41684_160275# VSS nfet_06v0 ad=13p pd=50.52u as=13p ps=50.52u w=50u l=0.7u
X550 a_41684_160275# a_41684_160275# VSS VSS nfet_06v0 ad=13p pd=50.52u as=13p ps=50.52u w=50u l=0.7u
X551 a_41684_148611# ESD_RAIL ESD_RAIL VSS nfet_06v0 ad=13p pd=50.52u as=13p ps=50.52u w=50u l=0.7u
X552 VSS RX_P VSS ppolyf_u_1k_6p0 r_width=1u r_length=0.31954m
X553 a_41684_160275# a_41684_160275# VSS VSS nfet_06v0 ad=13p pd=50.52u as=13p ps=50.52u w=50u l=0.7u
X554 ESD_RAIL ESD_RAIL a_41684_148611# VSS nfet_06v0 ad=13p pd=50.52u as=13p ps=50.52u w=50u l=0.7u
X555 ESD_RAIL a_42245_90628# VSS VSS nfet_06v0 ad=13p pd=50.52u as=13p ps=50.52u w=50u l=0.7u
D12 VSS ESD_RAIL diode_nd2ps_06v0 pj=82u area=40p
X556 VSS a_41684_160275# a_41684_160275# VSS nfet_06v0 ad=13p pd=50.52u as=13p ps=50.52u w=50u l=0.7u
X557 a_41684_160275# a_41684_160275# VSS VSS nfet_06v0 ad=13p pd=50.52u as=13p ps=50.52u w=50u l=0.7u
X558 VDD FS_P_GATE FS_P_WELL FS_P_WELL pfet_03v3 ad=6.16p pd=28.88u as=6.16p ps=28.88u w=14u l=0.28u
X559 ESD_RAIL ESD_RAIL a_41684_148611# VSS nfet_06v0 ad=13p pd=50.52u as=13p ps=50.52u w=50u l=0.7u
X560 VSS a_41684_160275# a_41684_160275# VSS nfet_06v0 ad=13p pd=50.52u as=13p ps=50.52u w=50u l=0.7u
X561 ESD_RAIL VSS cap_mim_2f0_m4m5_noshield c_width=31.6u c_length=31.6u
X562 a_41684_148611# a_41684_148611# a_41684_160275# VSS nfet_06v0 ad=13p pd=50.52u as=13p ps=50.52u w=50u l=0.7u
X563 ESD_RAIL a_43813_117064# a_44789_117064# ESD_RAIL pfet_06v0 ad=1.3p pd=5.52u as=1.3p ps=5.52u w=5u l=0.7u
X564 a_41684_148611# ESD_RAIL ESD_RAIL VSS nfet_06v0 ad=13p pd=50.52u as=13p ps=50.52u w=50u l=0.7u
X565 a_41684_160275# a_41684_160275# VSS VSS nfet_06v0 ad=13p pd=50.52u as=13p ps=50.52u w=50u l=0.7u
X566 a_41684_160275# a_41684_160275# VSS VSS nfet_06v0 ad=13p pd=50.52u as=13p ps=50.52u w=50u l=0.7u
X567 VDD FS_P_GATE FS_P_WELL FS_P_WELL pfet_03v3 ad=6.16p pd=28.88u as=6.16p ps=28.88u w=14u l=0.28u
X568 PULLUP_N_OUT PAD_N VSS ppolyf_u_1k r_width=1u r_length=1.18u
X569 ESD_RAIL ESD_RAIL a_41684_148611# VSS nfet_06v0 ad=13p pd=50.52u as=13p ps=50.52u w=50u l=0.7u
X570 VSS a_41684_160275# a_41684_160275# VSS nfet_06v0 ad=13p pd=50.52u as=13p ps=50.52u w=50u l=0.7u
X571 a_41684_148611# ESD_RAIL ESD_RAIL VSS nfet_06v0 ad=13p pd=50.52u as=13p ps=50.52u w=50u l=0.7u
X572 VDD FS_P_GATE FS_P_WELL FS_P_WELL pfet_03v3 ad=6.16p pd=28.88u as=6.16p ps=28.88u w=14u l=0.28u
X573 a_41684_148611# ESD_RAIL ESD_RAIL VSS nfet_06v0 ad=13p pd=50.52u as=13p ps=50.52u w=50u l=0.7u
X574 FS_N_WELL FS_N_BLEED_0 VSS ppolyf_u_1k r_width=1u r_length=12.5u
D13 VSS PAD_N diode_nd2ps_06v0 pj=51.8u area=22.5p
X575 a_42245_90628# a_44789_117064# ESD_RAIL ESD_RAIL pfet_06v0 ad=1.3p pd=5.52u as=1.3p ps=5.52u w=5u l=0.7u
X576 ESD_RAIL ESD_RAIL a_41684_148611# VSS nfet_06v0 ad=13p pd=50.52u as=13p ps=50.52u w=50u l=0.7u
X577 a_41684_148611# ESD_RAIL ESD_RAIL VSS nfet_06v0 ad=13p pd=50.52u as=13p ps=50.52u w=50u l=0.7u
X578 a_41684_160275# a_41684_160275# VSS VSS nfet_06v0 ad=13p pd=50.52u as=13p ps=50.52u w=50u l=0.7u
X579 a_41684_148611# a_41684_148611# a_41684_160275# VSS nfet_06v0 ad=13p pd=50.52u as=13p ps=50.52u w=50u l=0.7u
X580 ESD_RAIL ESD_RAIL a_41684_148611# VSS nfet_06v0 ad=13p pd=50.52u as=13p ps=50.52u w=50u l=0.7u
X581 PULLUP_N_GATE VDD PULLUP_N_WELL PULLUP_N_WELL pfet_03v3 ad=1.76p pd=8.88u as=1.76p ps=8.88u w=4u l=0.28u
X582 a_41684_160275# a_41684_148611# a_41684_148611# VSS nfet_06v0 ad=13p pd=50.52u as=13p ps=50.52u w=50u l=0.7u
X583 ESD_RAIL ESD_RAIL a_41684_148611# VSS nfet_06v0 ad=13p pd=50.52u as=13p ps=50.52u w=50u l=0.7u
X584 VSS a_41684_160275# a_41684_160275# VSS nfet_06v0 ad=13p pd=50.52u as=13p ps=50.52u w=50u l=0.7u
X585 FS_N_OUT FS_N_GATE FS_N_WELL FS_N_WELL pfet_03v3 ad=6.16p pd=28.88u as=6.16p ps=28.88u w=14u l=0.28u
X586 PULLUP_P_WELL PULLUP_P_BLEED_0 VSS ppolyf_u_1k r_width=1u r_length=12.5u
X587 ESD_RAIL ESD_RAIL a_41684_148611# VSS nfet_06v0 ad=13p pd=50.52u as=13p ps=50.52u w=50u l=0.7u
X588 a_41684_148611# ESD_RAIL ESD_RAIL VSS nfet_06v0 ad=13p pd=50.52u as=13p ps=50.52u w=50u l=0.7u
X589 a_41684_160275# a_41684_160275# VSS VSS nfet_06v0 ad=13p pd=50.52u as=13p ps=50.52u w=50u l=0.7u
X590 a_41684_148611# a_41684_148611# a_41684_160275# VSS nfet_06v0 ad=13p pd=50.52u as=13p ps=50.52u w=50u l=0.7u
X591 a_41684_160275# a_41684_148611# a_41684_148611# VSS nfet_06v0 ad=13p pd=50.52u as=13p ps=50.52u w=50u l=0.7u
X592 HS_P_6 HS_PBIAS VDD VDD pfet_03v3 ad=8.8p pd=40.88u as=8.8p ps=40.88u w=20u l=1u
X593 ESD_RAIL ESD_RAIL a_41684_148611# VSS nfet_06v0 ad=13p pd=50.52u as=13p ps=50.52u w=50u l=0.7u
X594 a_43813_117064# a_41005_131545# ESD_RAIL ESD_RAIL pfet_06v0 ad=1.3p pd=5.52u as=2.2p ps=10.88u w=5u l=0.7u
X595 VSS a_41684_160275# a_41684_160275# VSS nfet_06v0 ad=13p pd=50.52u as=13p ps=50.52u w=50u l=0.7u
X596 ESD_RAIL a_42245_90628# VSS VSS nfet_06v0 ad=22p pd=0.10088m as=13p ps=50.52u w=50u l=0.7u
X597 VDD FS_N_GATE FS_N_WELL FS_N_WELL pfet_03v3 ad=6.16p pd=28.88u as=6.16p ps=28.88u w=14u l=0.28u
X598 a_41684_148611# ESD_RAIL ESD_RAIL VSS nfet_06v0 ad=13p pd=50.52u as=13p ps=50.52u w=50u l=0.7u
X599 ESD_RAIL ESD_RAIL a_41684_148611# VSS nfet_06v0 ad=13p pd=50.52u as=13p ps=50.52u w=50u l=0.7u
X600 a_41684_160275# a_41684_148611# a_41684_148611# VSS nfet_06v0 ad=13p pd=50.52u as=13p ps=50.52u w=50u l=0.7u
X601 ESD_RAIL ESD_RAIL a_41684_148611# VSS nfet_06v0 ad=13p pd=50.52u as=13p ps=50.52u w=50u l=0.7u
X602 a_41684_148611# a_41684_148611# a_41684_160275# VSS nfet_06v0 ad=13p pd=50.52u as=13p ps=50.52u w=50u l=0.7u
X603 ESD_RAIL a_42245_90628# VSS VSS nfet_06v0 ad=13p pd=50.52u as=13p ps=50.52u w=50u l=0.7u
X604 VSS a_42245_90628# ESD_RAIL VSS nfet_06v0 ad=13p pd=50.52u as=13p ps=50.52u w=50u l=0.7u
X605 VDD FS_N_GATE FS_N_WELL FS_N_WELL pfet_03v3 ad=6.16p pd=28.88u as=6.16p ps=28.88u w=14u l=0.28u
X606 ESD_RAIL ESD_RAIL a_41684_148611# VSS nfet_06v0 ad=13p pd=50.52u as=13p ps=50.52u w=50u l=0.7u
X607 a_41684_148611# ESD_RAIL ESD_RAIL VSS nfet_06v0 ad=13p pd=50.52u as=13p ps=50.52u w=50u l=0.7u
X608 VSS a_41684_160275# a_41684_160275# VSS nfet_06v0 ad=13p pd=50.52u as=13p ps=50.52u w=50u l=0.7u
X609 VDD FS_P_GATE FS_P_WELL FS_P_WELL pfet_03v3 ad=6.16p pd=28.88u as=6.16p ps=28.88u w=14u l=0.28u
X610 a_41684_160275# a_41684_148611# a_41684_148611# VSS nfet_06v0 ad=13p pd=50.52u as=13p ps=50.52u w=50u l=0.7u
X611 VSS a_42245_90628# ESD_RAIL VSS nfet_06v0 ad=13p pd=50.52u as=13p ps=50.52u w=50u l=0.7u
X612 a_41684_148611# ESD_RAIL ESD_RAIL VSS nfet_06v0 ad=13p pd=50.52u as=13p ps=50.52u w=50u l=0.7u
X613 a_41684_148611# a_41684_148611# a_41684_160275# VSS nfet_06v0 ad=13p pd=50.52u as=13p ps=50.52u w=50u l=0.7u
X614 a_41684_160275# a_41684_160275# VSS VSS nfet_06v0 ad=13p pd=50.52u as=13p ps=50.52u w=50u l=0.7u
X615 ESD_RAIL ESD_RAIL a_41684_148611# VSS nfet_06v0 ad=13p pd=50.52u as=13p ps=50.52u w=50u l=0.7u
X616 a_44789_117064# a_43813_117064# ESD_RAIL ESD_RAIL pfet_06v0 ad=1.3p pd=5.52u as=1.3p ps=5.52u w=5u l=0.7u
X617 ESD_RAIL ESD_RAIL a_41684_148611# VSS nfet_06v0 ad=13p pd=50.52u as=13p ps=50.52u w=50u l=0.7u
X618 VSS a_41684_160275# a_41684_160275# VSS nfet_06v0 ad=13p pd=50.52u as=13p ps=50.52u w=50u l=0.7u
X619 VDD FS_P_GATE FS_P_WELL FS_P_WELL pfet_03v3 ad=6.16p pd=28.88u as=6.16p ps=28.88u w=14u l=0.28u
X620 HS_P_12 HS_PBIAS VDD VDD pfet_03v3 ad=8.8p pd=40.88u as=8.8p ps=40.88u w=20u l=1u
X621 a_41684_148611# ESD_RAIL ESD_RAIL VSS nfet_06v0 ad=13p pd=50.52u as=13p ps=50.52u w=50u l=0.7u
X622 a_41684_160275# a_41684_148611# a_41684_148611# VSS nfet_06v0 ad=13p pd=50.52u as=13p ps=50.52u w=50u l=0.7u
X623 a_41684_148611# a_41684_148611# a_41684_160275# VSS nfet_06v0 ad=13p pd=50.52u as=13p ps=50.52u w=50u l=0.7u
X624 a_41684_148611# a_41684_148611# a_41684_160275# VSS nfet_06v0 ad=13p pd=50.52u as=13p ps=50.52u w=50u l=0.7u
X625 TERM_P_R DIFF_ENABLE TERM_N_R VSS nfet_03v3 ad=8.8p pd=40.88u as=8.8p ps=40.88u w=20u l=0.28u
X626 a_41684_160275# a_41684_160275# VSS VSS nfet_06v0 ad=13p pd=50.52u as=13p ps=50.52u w=50u l=0.7u
X627 a_41684_160275# a_41684_148611# a_41684_148611# VSS nfet_06v0 ad=13p pd=50.52u as=13p ps=50.52u w=50u l=0.7u
X628 TERM_GATE_N_BLEED_0 TERM_GATE_N_BLEED_1 VSS ppolyf_u_1k r_width=1u r_length=12.5u
X629 a_41684_148611# a_41684_148611# a_41684_160275# VSS nfet_06v0 ad=13p pd=50.52u as=13p ps=50.52u w=50u l=0.7u
X630 ESD_RAIL ESD_RAIL a_41684_148611# VSS nfet_06v0 ad=13p pd=50.52u as=13p ps=50.52u w=50u l=0.7u
X631 a_41684_160275# a_41684_148611# a_41684_148611# VSS nfet_06v0 ad=13p pd=50.52u as=13p ps=50.52u w=50u l=0.7u
X632 a_41684_148611# ESD_RAIL ESD_RAIL VSS nfet_06v0 ad=13p pd=50.52u as=13p ps=50.52u w=50u l=0.7u
X633 PULLUP_P_BLEED_3 PULLUP_P_BLEED_4 VSS ppolyf_u_1k r_width=1u r_length=12.5u
X634 a_41684_148611# a_41684_148611# a_41684_160275# VSS nfet_06v0 ad=13p pd=50.52u as=13p ps=50.52u w=50u l=0.7u
X635 ESD_RAIL ESD_RAIL a_41684_148611# VSS nfet_06v0 ad=13p pd=50.52u as=13p ps=50.52u w=50u l=0.7u
X636 VDD FS_N_GATE FS_N_WELL FS_N_WELL pfet_03v3 ad=6.16p pd=28.88u as=6.16p ps=28.88u w=14u l=0.28u
X637 a_41684_160275# a_41684_148611# a_41684_148611# VSS nfet_06v0 ad=13p pd=50.52u as=13p ps=50.52u w=50u l=0.7u
X638 a_41684_148611# ESD_RAIL ESD_RAIL VSS nfet_06v0 ad=13p pd=50.52u as=13p ps=50.52u w=50u l=0.7u
X639 VSS a_41684_160275# a_41684_160275# VSS nfet_06v0 ad=13p pd=50.52u as=13p ps=50.52u w=50u l=0.7u
X640 VDD FS_P_GATE FS_P_WELL FS_P_WELL pfet_03v3 ad=6.16p pd=28.88u as=6.16p ps=28.88u w=14u l=0.28u
X641 a_41684_148611# a_41684_148611# a_41684_160275# VSS nfet_06v0 ad=13p pd=50.52u as=13p ps=50.52u w=50u l=0.7u
D14 VSS FS_LOW_N diode_nd2ps_03v3 pj=4.92u area=1.5129p
X642 a_41684_160275# a_41684_160275# VSS VSS nfet_06v0 ad=13p pd=50.52u as=13p ps=50.52u w=50u l=0.7u
X643 VDD FS_N_GATE FS_N_WELL FS_N_WELL pfet_03v3 ad=6.16p pd=28.88u as=6.16p ps=28.88u w=14u l=0.28u
X644 a_41684_160275# a_41684_148611# a_41684_148611# VSS nfet_06v0 ad=13p pd=50.52u as=13p ps=50.52u w=50u l=0.7u
X645 TERM_GATE_P TERM_OR_P_B VSS VSS nfet_03v3 ad=1.76p pd=8.88u as=1.76p ps=8.88u w=4u l=0.28u
X646 HS_N_12 HS_PBIAS VDD VDD pfet_03v3 ad=8.8p pd=40.88u as=8.8p ps=40.88u w=20u l=1u
X647 VSS a_42245_90628# ESD_RAIL VSS nfet_06v0 ad=13p pd=50.52u as=22p ps=0.10088m w=50u l=0.7u
X648 ESD_RAIL a_44789_117064# a_42245_90628# ESD_RAIL pfet_06v0 ad=1.3p pd=5.52u as=1.3p ps=5.52u w=5u l=0.7u
X649 HS_N_8 HS_N PAD_N VSS nfet_06v0 ad=8.8p pd=40.88u as=8.8p ps=40.88u w=20u l=0.7u
X650 a_41684_148611# a_41684_148611# a_41684_160275# VSS nfet_06v0 ad=13p pd=50.52u as=13p ps=50.52u w=50u l=0.7u
X651 VSS a_42245_90628# ESD_RAIL VSS nfet_06v0 ad=13p pd=50.52u as=13p ps=50.52u w=50u l=0.7u
X652 PULLUP_N_BLEED_4 PULLUP_N_BLEED_5 VSS ppolyf_u_1k r_width=1u r_length=12.5u
X653 a_41684_160275# a_41684_148611# a_41684_148611# VSS nfet_06v0 ad=13p pd=50.52u as=13p ps=50.52u w=50u l=0.7u
X654 a_41684_160275# a_41684_148611# a_41684_148611# VSS nfet_06v0 ad=13p pd=50.52u as=13p ps=50.52u w=50u l=0.7u
X655 VSS a_42245_90628# ESD_RAIL VSS nfet_06v0 ad=13p pd=50.52u as=13p ps=50.52u w=50u l=0.7u
X656 a_41684_148611# ESD_RAIL ESD_RAIL VSS nfet_06v0 ad=13p pd=50.52u as=13p ps=50.52u w=50u l=0.7u
X657 a_41684_148611# a_41684_148611# a_41684_160275# VSS nfet_06v0 ad=13p pd=50.52u as=13p ps=50.52u w=50u l=0.7u
X658 a_41684_160275# a_41684_160275# VSS VSS nfet_06v0 ad=13p pd=50.52u as=13p ps=50.52u w=50u l=0.7u
X659 ESD_RAIL ESD_RAIL a_41684_148611# VSS nfet_06v0 ad=13p pd=50.52u as=13p ps=50.52u w=50u l=0.7u
X660 a_41684_148611# ESD_RAIL ESD_RAIL VSS nfet_06v0 ad=13p pd=50.52u as=13p ps=50.52u w=50u l=0.7u
X661 a_41684_160275# a_41684_148611# a_41684_148611# VSS nfet_06v0 ad=13p pd=50.52u as=13p ps=50.52u w=50u l=0.7u
X662 TERM_OR_P_B FS_LOW_P TERM_OR_P_S VDD pfet_03v3 ad=1.76p pd=8.88u as=1.76p ps=8.88u w=4u l=0.28u
X663 a_41684_148611# a_41684_148611# a_41684_160275# VSS nfet_06v0 ad=13p pd=50.52u as=13p ps=50.52u w=50u l=0.7u
X664 ESD_RAIL ESD_RAIL a_41684_148611# VSS nfet_06v0 ad=13p pd=50.52u as=13p ps=50.52u w=50u l=0.7u
X665 VDD FS_N_GATE FS_N_WELL FS_N_WELL pfet_03v3 ad=6.16p pd=28.88u as=6.16p ps=28.88u w=14u l=0.28u
X666 a_41684_148611# a_41684_148611# a_41684_160275# VSS nfet_06v0 ad=13p pd=50.52u as=13p ps=50.52u w=50u l=0.7u
X667 a_41684_160275# a_41684_148611# a_41684_148611# VSS nfet_06v0 ad=13p pd=50.52u as=13p ps=50.52u w=50u l=0.7u
X668 a_41684_148611# a_41684_148611# a_41684_160275# VSS nfet_06v0 ad=13p pd=50.52u as=13p ps=50.52u w=50u l=0.7u
X669 a_41684_160275# a_41684_148611# a_41684_148611# VSS nfet_06v0 ad=13p pd=50.52u as=13p ps=50.52u w=50u l=0.7u
X670 a_41684_148611# a_41684_148611# a_41684_160275# VSS nfet_06v0 ad=13p pd=50.52u as=13p ps=50.52u w=50u l=0.7u
X671 a_41684_160275# a_41684_148611# a_41684_148611# VSS nfet_06v0 ad=13p pd=50.52u as=13p ps=50.52u w=50u l=0.7u
X672 a_41684_148611# a_41684_148611# a_41684_160275# VSS nfet_06v0 ad=13p pd=50.52u as=13p ps=50.52u w=50u l=0.7u
X673 TERM_GATE_P TERM_OR_P_B VDD VDD pfet_03v3 ad=3.52p pd=16.88u as=3.52p ps=16.88u w=8u l=0.28u
X674 VSS RX_N VSS ppolyf_u_1k_6p0 r_width=1u r_length=0.31954m
X675 HS_N_10 HS_PBIAS VDD VDD pfet_03v3 ad=8.8p pd=40.88u as=8.8p ps=40.88u w=20u l=1u
X676 a_41684_160275# a_41684_160275# VSS VSS nfet_06v0 ad=13p pd=50.52u as=13p ps=50.52u w=50u l=0.7u
X677 a_41684_148611# ESD_RAIL ESD_RAIL VSS nfet_06v0 ad=13p pd=50.52u as=13p ps=50.52u w=50u l=0.7u
X678 VSS a_41684_160275# a_41684_160275# VSS nfet_06v0 ad=13p pd=50.52u as=13p ps=50.52u w=50u l=0.7u
X679 ESD_RAIL ESD_RAIL a_41684_148611# VSS nfet_06v0 ad=13p pd=50.52u as=13p ps=50.52u w=50u l=0.7u
D15 PAD_P ESD_RAIL diode_pd2nw_06v0 pj=51.8u area=22.5p
X680 TERM_OR_P_B FS_LOW_P TERM_OR_P_NS VSS nfet_03v3 ad=0.88p pd=4.88u as=0.88p ps=4.88u w=2u l=0.28u
X681 FS_N_BLEED_3 FS_N_BLEED_4 VSS ppolyf_u_1k r_width=1u r_length=12.5u
X682 a_41684_160275# a_41684_160275# VSS VSS nfet_06v0 ad=13p pd=50.52u as=13p ps=50.52u w=50u l=0.7u
X683 ESD_RAIL a_42245_90628# VSS VSS nfet_06v0 ad=13p pd=50.52u as=13p ps=50.52u w=50u l=0.7u
X684 VSS a_41684_160275# a_41684_160275# VSS nfet_06v0 ad=13p pd=50.52u as=13p ps=50.52u w=50u l=0.7u
X685 PULLUP_N_BLEED_0 PULLUP_N_BLEED_1 VSS ppolyf_u_1k r_width=1u r_length=12.5u
D16 VSS FS_LOW_P diode_nd2ps_03v3 pj=8.76u area=4.7961p
X686 FS_P_BLEED_4 FS_P_BLEED_5 VSS ppolyf_u_1k r_width=1u r_length=12.5u
X687 a_41684_148611# a_41684_148611# a_41684_160275# VSS nfet_06v0 ad=13p pd=50.52u as=13p ps=50.52u w=50u l=0.7u
X688 VSS a_42245_90628# ESD_RAIL VSS nfet_06v0 ad=13p pd=50.52u as=13p ps=50.52u w=50u l=0.7u
X689 FS_P_OUT FS_P_GATE FS_P_WELL FS_P_WELL pfet_03v3 ad=6.16p pd=28.88u as=6.16p ps=28.88u w=14u l=0.28u
X690 a_41684_160275# a_41684_160275# VSS VSS nfet_06v0 ad=13p pd=50.52u as=13p ps=50.52u w=50u l=0.7u
X691 VSS a_43813_117064# a_44789_117064# VSS nfet_06v0 ad=1.3p pd=5.52u as=1.3p ps=5.52u w=5u l=0.7u
X692 VDD PULLUP_P_GATE PULLUP_P_WELL PULLUP_P_WELL pfet_03v3 ad=8.8p pd=40.88u as=8.8p ps=40.88u w=20u l=0.28u
X693 a_41684_160275# a_41684_160275# VSS VSS nfet_06v0 ad=13p pd=50.52u as=13p ps=50.52u w=50u l=0.7u
X694 VSS a_41684_160275# a_41684_160275# VSS nfet_06v0 ad=13p pd=50.52u as=13p ps=50.52u w=50u l=0.7u
X695 ESD_RAIL ESD_RAIL a_41684_148611# VSS nfet_06v0 ad=13p pd=50.52u as=13p ps=50.52u w=50u l=0.7u
X696 FS_N_BLEED_5 FS_N_BLEED_6 VSS ppolyf_u_1k r_width=1u r_length=12.5u
X697 a_41684_160275# a_41684_160275# VSS VSS nfet_06v0 ad=13p pd=50.52u as=13p ps=50.52u w=50u l=0.7u
X698 VDD FS_N_GATE FS_N_WELL FS_N_WELL pfet_03v3 ad=6.16p pd=28.88u as=6.16p ps=28.88u w=14u l=0.28u
X699 a_41684_148611# a_41684_148611# a_41684_160275# VSS nfet_06v0 ad=13p pd=50.52u as=13p ps=50.52u w=50u l=0.7u
X700 a_41684_160275# a_41684_160275# VSS VSS nfet_06v0 ad=13p pd=50.52u as=13p ps=50.52u w=50u l=0.7u
X701 VSS a_41684_160275# a_41684_160275# VSS nfet_06v0 ad=13p pd=50.52u as=13p ps=50.52u w=50u l=0.7u
X702 VSS a_41684_160275# a_41684_160275# VSS nfet_06v0 ad=13p pd=50.52u as=13p ps=50.52u w=50u l=0.7u
X703 ESD_RAIL a_42245_90628# VSS VSS nfet_06v0 ad=22p pd=0.10088m as=13p ps=50.52u w=50u l=0.7u
X704 HS_N_1 HS_N PAD_N VSS nfet_06v0 ad=8.8p pd=40.88u as=8.8p ps=40.88u w=20u l=0.7u
X705 a_41684_160275# a_41684_160275# VSS VSS nfet_06v0 ad=13p pd=50.52u as=13p ps=50.52u w=50u l=0.7u
X706 VSS a_42245_90628# ESD_RAIL VSS nfet_06v0 ad=13p pd=50.52u as=13p ps=50.52u w=50u l=0.7u
X707 a_41684_160275# a_41684_148611# a_41684_148611# VSS nfet_06v0 ad=13p pd=50.52u as=13p ps=50.52u w=50u l=0.7u
X708 HS_N_4 HS_PBIAS VDD VDD pfet_03v3 ad=8.8p pd=40.88u as=8.8p ps=40.88u w=20u l=1u
X709 VSS a_41684_160275# a_41684_160275# VSS nfet_06v0 ad=13p pd=50.52u as=13p ps=50.52u w=50u l=0.7u
X710 VSS a_41684_160275# a_41684_160275# VSS nfet_06v0 ad=13p pd=50.52u as=13p ps=50.52u w=50u l=0.7u
D17 VSS PAD_P diode_nd2ps_06v0 pj=51.8u area=22.5p
X711 FS_N_GATE FS_HIGH_N FS_N_CONTROL_S VSS nfet_06v0 ad=0.88p pd=4.88u as=0.88p ps=4.88u w=2u l=0.7u
X712 a_41684_160275# a_41684_160275# VSS VSS nfet_06v0 ad=13p pd=50.52u as=13p ps=50.52u w=50u l=0.7u
X713 VSS a_44789_117064# a_42245_90628# VSS nfet_06v0 ad=1.3p pd=5.52u as=1.3p ps=5.52u w=5u l=0.7u
X714 VDD FS_N_GATE FS_N_WELL FS_N_WELL pfet_03v3 ad=6.16p pd=28.88u as=6.16p ps=28.88u w=14u l=0.28u
X715 a_41684_160275# a_41684_148611# a_41684_148611# VSS nfet_06v0 ad=13p pd=50.52u as=13p ps=50.52u w=50u l=0.7u
X716 VSS a_41684_160275# a_41684_160275# VSS nfet_06v0 ad=13p pd=50.52u as=13p ps=50.52u w=50u l=0.7u
X717 ESD_RAIL ESD_RAIL a_41684_148611# VSS nfet_06v0 ad=13p pd=50.52u as=13p ps=50.52u w=50u l=0.7u
X718 a_41684_160275# a_41684_160275# VSS VSS nfet_06v0 ad=13p pd=50.52u as=13p ps=50.52u w=50u l=0.7u
X719 VSS a_44789_117064# a_42245_90628# VSS nfet_06v0 ad=1.3p pd=5.52u as=1.3p ps=5.52u w=5u l=0.7u
X720 TERM_GATE_N TERM_OR_N_B VSS VSS nfet_03v3 ad=1.76p pd=8.88u as=1.76p ps=8.88u w=4u l=0.28u
X721 VSS a_41684_160275# a_41684_160275# VSS nfet_06v0 ad=13p pd=50.52u as=13p ps=50.52u w=50u l=0.7u
X722 a_41684_148611# ESD_RAIL ESD_RAIL VSS nfet_06v0 ad=13p pd=50.52u as=13p ps=50.52u w=50u l=0.7u
X723 ESD_RAIL a_44789_117064# a_42245_90628# ESD_RAIL pfet_06v0 ad=1.3p pd=5.52u as=1.3p ps=5.52u w=5u l=0.7u
X724 a_41684_160275# a_41684_160275# VSS VSS nfet_06v0 ad=13p pd=50.52u as=13p ps=50.52u w=50u l=0.7u
X725 VSS a_41684_160275# a_41684_160275# VSS nfet_06v0 ad=13p pd=50.52u as=13p ps=50.52u w=50u l=0.7u
X726 a_41684_160275# a_41684_160275# VSS VSS nfet_06v0 ad=13p pd=50.52u as=13p ps=50.52u w=50u l=0.7u
X727 ESD_RAIL ESD_RAIL a_41684_148611# VSS nfet_06v0 ad=13p pd=50.52u as=13p ps=50.52u w=50u l=0.7u
X728 VSS a_41684_160275# a_41684_160275# VSS nfet_06v0 ad=13p pd=50.52u as=13p ps=50.52u w=50u l=0.7u
X729 a_41684_160275# a_41684_160275# VSS VSS nfet_06v0 ad=13p pd=50.52u as=13p ps=50.52u w=50u l=0.7u
X730 a_41684_148611# ESD_RAIL ESD_RAIL VSS nfet_06v0 ad=13p pd=50.52u as=13p ps=50.52u w=50u l=0.7u
X731 VSS a_41684_160275# a_41684_160275# VSS nfet_06v0 ad=13p pd=50.52u as=13p ps=50.52u w=50u l=0.7u
X732 a_41005_131545# a_53878_131545# ESD_RAIL ppolyf_u r_width=0.8u r_length=63.855u
X733 a_41684_148611# a_41684_148611# a_41684_160275# VSS nfet_06v0 ad=13p pd=50.52u as=13p ps=50.52u w=50u l=0.7u
X734 VSS a_42245_90628# ESD_RAIL VSS nfet_06v0 ad=13p pd=50.52u as=13p ps=50.52u w=50u l=0.7u
X735 HS_N_10 HS_N PAD_N VSS nfet_06v0 ad=8.8p pd=40.88u as=8.8p ps=40.88u w=20u l=0.7u
X736 a_41684_160275# a_41684_160275# VSS VSS nfet_06v0 ad=13p pd=50.52u as=13p ps=50.52u w=50u l=0.7u
X737 a_41684_160275# a_41684_160275# VSS VSS nfet_06v0 ad=13p pd=50.52u as=13p ps=50.52u w=50u l=0.7u
X738 ESD_RAIL ESD_RAIL a_41684_148611# VSS nfet_06v0 ad=13p pd=50.52u as=13p ps=50.52u w=50u l=0.7u
X739 VSS a_41684_160275# a_41684_160275# VSS nfet_06v0 ad=13p pd=50.52u as=13p ps=50.52u w=50u l=0.7u
X740 ESD_RAIL ESD_RAIL a_41684_148611# VSS nfet_06v0 ad=13p pd=50.52u as=13p ps=50.52u w=50u l=0.7u
X741 a_41684_148611# ESD_RAIL ESD_RAIL VSS nfet_06v0 ad=13p pd=50.52u as=13p ps=50.52u w=50u l=0.7u
X742 PAD_N BYPASS_ENABLE RX_N VSS nfet_06v0 ad=8.8p pd=40.88u as=8.8p ps=40.88u w=20u l=0.7u
X743 TERM_P_R TERM_GATE_P TERM_VCM VSS nfet_03v3 ad=8.8p pd=40.88u as=8.8p ps=40.88u w=20u l=0.28u
X744 ESD_RAIL ESD_RAIL a_41684_148611# VSS nfet_06v0 ad=13p pd=50.52u as=13p ps=50.52u w=50u l=0.7u
X745 VDD FS_N_GATE FS_N_WELL FS_N_WELL pfet_03v3 ad=6.16p pd=28.88u as=6.16p ps=28.88u w=14u l=0.28u
X746 ESD_RAIL a_42245_90628# VSS VSS nfet_06v0 ad=13p pd=50.52u as=13p ps=50.52u w=50u l=0.7u
D18 PAD_N ESD_RAIL diode_pd2nw_06v0 pj=51.8u area=22.5p
X747 VSS a_41684_160275# a_41684_160275# VSS nfet_06v0 ad=13p pd=50.52u as=13p ps=50.52u w=50u l=0.7u
X748 a_41684_160275# a_41684_160275# VSS VSS nfet_06v0 ad=13p pd=50.52u as=13p ps=50.52u w=50u l=0.7u
X749 ESD_RAIL ESD_RAIL a_41684_148611# VSS nfet_06v0 ad=13p pd=50.52u as=13p ps=50.52u w=50u l=0.7u
X750 a_44789_117064# a_43813_117064# VSS VSS nfet_06v0 ad=1.3p pd=5.52u as=1.3p ps=5.52u w=5u l=0.7u
X751 a_41684_148611# ESD_RAIL ESD_RAIL VSS nfet_06v0 ad=13p pd=50.52u as=13p ps=50.52u w=50u l=0.7u
X752 a_41684_160275# a_41684_160275# VSS VSS nfet_06v0 ad=13p pd=50.52u as=13p ps=50.52u w=50u l=0.7u
X753 VSS a_41684_160275# a_41684_160275# VSS nfet_06v0 ad=13p pd=50.52u as=13p ps=50.52u w=50u l=0.7u
X754 a_41684_148611# ESD_RAIL ESD_RAIL VSS nfet_06v0 ad=13p pd=50.52u as=13p ps=50.52u w=50u l=0.7u
X755 ESD_RAIL a_42245_90628# VSS VSS nfet_06v0 ad=13p pd=50.52u as=13p ps=50.52u w=50u l=0.7u
X756 HS_N_3 HS_N PAD_N VSS nfet_06v0 ad=8.8p pd=40.88u as=8.8p ps=40.88u w=20u l=0.7u
X757 VDD FS_N_GATE FS_N_WELL FS_N_WELL pfet_03v3 ad=6.16p pd=28.88u as=6.16p ps=28.88u w=14u l=0.28u
X758 a_41684_160275# a_41684_160275# VSS VSS nfet_06v0 ad=13p pd=50.52u as=13p ps=50.52u w=50u l=0.7u
X759 ESD_RAIL ESD_RAIL a_41684_148611# VSS nfet_06v0 ad=13p pd=50.52u as=13p ps=50.52u w=50u l=0.7u
X760 a_41684_160275# a_41684_148611# a_41684_148611# VSS nfet_06v0 ad=13p pd=50.52u as=13p ps=50.52u w=50u l=0.7u
X761 a_41684_148611# ESD_RAIL ESD_RAIL VSS nfet_06v0 ad=13p pd=50.52u as=13p ps=50.52u w=50u l=0.7u
X762 VSS a_41684_160275# a_41684_160275# VSS nfet_06v0 ad=13p pd=50.52u as=13p ps=50.52u w=50u l=0.7u
X763 VSS a_41684_160275# a_41684_160275# VSS nfet_06v0 ad=13p pd=50.52u as=13p ps=50.52u w=50u l=0.7u
X764 a_41684_148611# ESD_RAIL ESD_RAIL VSS nfet_06v0 ad=13p pd=50.52u as=13p ps=50.52u w=50u l=0.7u
X765 PULLUP_N_OUT PULLUP_N_GATE PULLUP_N_WELL PULLUP_N_WELL pfet_03v3 ad=8.8p pd=40.88u as=8.8p ps=40.88u w=20u l=0.28u
X766 VDD FS_N_GATE FS_N_WELL FS_N_WELL pfet_03v3 ad=6.16p pd=28.88u as=6.16p ps=28.88u w=14u l=0.28u
X767 FS_P_OUT FS_P_GATE FS_P_WELL FS_P_WELL pfet_03v3 ad=6.16p pd=28.88u as=6.16p ps=28.88u w=14u l=0.28u
X768 a_41684_160275# a_41684_160275# VSS VSS nfet_06v0 ad=13p pd=50.52u as=13p ps=50.52u w=50u l=0.7u
X769 VSS a_42245_90628# ESD_RAIL VSS nfet_06v0 ad=13p pd=50.52u as=13p ps=50.52u w=50u l=0.7u
X770 ESD_RAIL ESD_RAIL a_41684_148611# VSS nfet_06v0 ad=13p pd=50.52u as=13p ps=50.52u w=50u l=0.7u
X771 a_41684_160275# a_41684_160275# VSS VSS nfet_06v0 ad=13p pd=50.52u as=13p ps=50.52u w=50u l=0.7u
X772 VSS a_41684_160275# a_41684_160275# VSS nfet_06v0 ad=13p pd=50.52u as=13p ps=50.52u w=50u l=0.7u
X773 VDD FS_N_GATE FS_N_WELL FS_N_WELL pfet_03v3 ad=6.16p pd=28.88u as=6.16p ps=28.88u w=14u l=0.28u
X774 VSS a_41684_160275# a_41684_160275# VSS nfet_06v0 ad=13p pd=50.52u as=13p ps=50.52u w=50u l=0.7u
X775 a_41684_148611# ESD_RAIL ESD_RAIL VSS nfet_06v0 ad=13p pd=50.52u as=13p ps=50.52u w=50u l=0.7u
X776 a_41684_160275# a_41684_160275# VSS VSS nfet_06v0 ad=13p pd=50.52u as=13p ps=50.52u w=50u l=0.7u
X777 ESD_RAIL ESD_RAIL a_41684_148611# VSS nfet_06v0 ad=13p pd=50.52u as=13p ps=50.52u w=50u l=0.7u
X778 a_41684_148611# ESD_RAIL ESD_RAIL VSS nfet_06v0 ad=13p pd=50.52u as=13p ps=50.52u w=50u l=0.7u
X779 TERM_N_R TERM_GATE_N TERM_VCM VSS nfet_03v3 ad=8.8p pd=40.88u as=8.8p ps=40.88u w=20u l=0.28u
X780 a_41684_160275# a_41684_160275# VSS VSS nfet_06v0 ad=13p pd=50.52u as=13p ps=50.52u w=50u l=0.7u
X781 ESD_RAIL ESD_RAIL a_41684_148611# VSS nfet_06v0 ad=13p pd=50.52u as=13p ps=50.52u w=50u l=0.7u
X782 a_41684_148611# ESD_RAIL ESD_RAIL VSS nfet_06v0 ad=13p pd=50.52u as=13p ps=50.52u w=50u l=0.7u
X783 ESD_RAIL ESD_RAIL a_41684_148611# VSS nfet_06v0 ad=13p pd=50.52u as=13p ps=50.52u w=50u l=0.7u
X784 VSS a_41684_160275# a_41684_160275# VSS nfet_06v0 ad=13p pd=50.52u as=13p ps=50.52u w=50u l=0.7u
X785 a_41684_148611# ESD_RAIL ESD_RAIL VSS nfet_06v0 ad=13p pd=50.52u as=13p ps=50.52u w=50u l=0.7u
X786 ESD_RAIL ESD_RAIL a_41684_148611# VSS nfet_06v0 ad=13p pd=50.52u as=13p ps=50.52u w=50u l=0.7u
X787 a_41684_148611# ESD_RAIL ESD_RAIL VSS nfet_06v0 ad=13p pd=50.52u as=13p ps=50.52u w=50u l=0.7u
X788 VSS a_41684_160275# a_41684_160275# VSS nfet_06v0 ad=13p pd=50.52u as=13p ps=50.52u w=50u l=0.7u
X789 VDD FS_N_GATE FS_N_WELL FS_N_WELL pfet_03v3 ad=6.16p pd=28.88u as=6.16p ps=28.88u w=14u l=0.28u
X790 ESD_RAIL ESD_RAIL a_41684_148611# VSS nfet_06v0 ad=13p pd=50.52u as=13p ps=50.52u w=50u l=0.7u
X791 a_41005_132385# a_53878_132665# ESD_RAIL ppolyf_u r_width=0.8u r_length=63.855u
X792 a_41684_160275# a_41684_160275# VSS VSS nfet_06v0 ad=13p pd=50.52u as=13p ps=50.52u w=50u l=0.7u
X793 VSS a_41684_160275# a_41684_160275# VSS nfet_06v0 ad=13p pd=50.52u as=13p ps=50.52u w=50u l=0.7u
X794 a_41684_160275# a_41684_160275# VSS VSS nfet_06v0 ad=13p pd=50.52u as=13p ps=50.52u w=50u l=0.7u
X795 ESD_RAIL ESD_RAIL a_41684_148611# VSS nfet_06v0 ad=13p pd=50.52u as=13p ps=50.52u w=50u l=0.7u
X796 VSS a_41684_160275# a_41684_160275# VSS nfet_06v0 ad=13p pd=50.52u as=13p ps=50.52u w=50u l=0.7u
X797 VSS a_41684_160275# a_41684_160275# VSS nfet_06v0 ad=13p pd=50.52u as=13p ps=50.52u w=50u l=0.7u
X798 a_41684_148611# ESD_RAIL ESD_RAIL VSS nfet_06v0 ad=13p pd=50.52u as=13p ps=50.52u w=50u l=0.7u
X799 a_41684_160275# a_41684_148611# a_41684_148611# VSS nfet_06v0 ad=13p pd=50.52u as=13p ps=50.52u w=50u l=0.7u
X800 a_41684_160275# a_41684_160275# VSS VSS nfet_06v0 ad=13p pd=50.52u as=13p ps=50.52u w=50u l=0.7u
X801 ESD_RAIL ESD_RAIL a_41684_148611# VSS nfet_06v0 ad=13p pd=50.52u as=13p ps=50.52u w=50u l=0.7u
X802 a_41684_148611# ESD_RAIL ESD_RAIL VSS nfet_06v0 ad=13p pd=50.52u as=13p ps=50.52u w=50u l=0.7u
X803 TERM_OR_N_B FS_LOW_N TERM_OR_N_S VDD pfet_03v3 ad=1.76p pd=8.88u as=1.76p ps=8.88u w=4u l=0.28u
X804 ESD_RAIL ESD_RAIL a_41684_148611# VSS nfet_06v0 ad=13p pd=50.52u as=13p ps=50.52u w=50u l=0.7u
X805 a_41684_148611# ESD_RAIL ESD_RAIL VSS nfet_06v0 ad=13p pd=50.52u as=13p ps=50.52u w=50u l=0.7u
X806 FS_P_OUT FS_P_GATE FS_P_WELL FS_P_WELL pfet_03v3 ad=6.16p pd=28.88u as=6.16p ps=28.88u w=14u l=0.28u
X807 a_41684_160275# a_41684_148611# a_41684_148611# VSS nfet_06v0 ad=13p pd=50.52u as=13p ps=50.52u w=50u l=0.7u
X808 a_41684_148611# a_41684_148611# a_41684_160275# VSS nfet_06v0 ad=13p pd=50.52u as=13p ps=50.52u w=50u l=0.7u
X809 a_41684_160275# a_41684_148611# a_41684_148611# VSS nfet_06v0 ad=13p pd=50.52u as=13p ps=50.52u w=50u l=0.7u
X810 VSS a_42245_90628# ESD_RAIL VSS nfet_06v0 ad=13p pd=50.52u as=13p ps=50.52u w=50u l=0.7u
X811 ESD_RAIL ESD_RAIL a_41684_148611# VSS nfet_06v0 ad=13p pd=50.52u as=13p ps=50.52u w=50u l=0.7u
X812 HS_N_0 HS_PBIAS VDD VDD pfet_03v3 ad=8.8p pd=40.88u as=8.8p ps=40.88u w=20u l=1u
X813 a_41684_160275# a_41684_148611# a_41684_148611# VSS nfet_06v0 ad=13p pd=50.52u as=13p ps=50.52u w=50u l=0.7u
X814 PULLUP_P_GATE VDD PULLUP_P_WELL PULLUP_P_WELL pfet_03v3 ad=1.76p pd=8.88u as=1.76p ps=8.88u w=4u l=0.28u
X815 a_41684_148611# ESD_RAIL ESD_RAIL VSS nfet_06v0 ad=13p pd=50.52u as=13p ps=50.52u w=50u l=0.7u
X816 a_41684_148611# ESD_RAIL ESD_RAIL VSS nfet_06v0 ad=13p pd=50.52u as=13p ps=50.52u w=50u l=0.7u
X817 FS_P_OUT FS_P_GATE FS_P_WELL FS_P_WELL pfet_03v3 ad=6.16p pd=28.88u as=6.16p ps=28.88u w=14u l=0.28u
X818 ESD_RAIL ESD_RAIL a_41684_148611# VSS nfet_06v0 ad=13p pd=50.52u as=13p ps=50.52u w=50u l=0.7u
X819 VSS a_42245_90628# ESD_RAIL VSS nfet_06v0 ad=13p pd=50.52u as=13p ps=50.52u w=50u l=0.7u
X820 ESD_RAIL ESD_RAIL a_41684_148611# VSS nfet_06v0 ad=13p pd=50.52u as=13p ps=50.52u w=50u l=0.7u
X821 a_41684_160275# a_41684_148611# a_41684_148611# VSS nfet_06v0 ad=13p pd=50.52u as=13p ps=50.52u w=50u l=0.7u
X822 HS_P_1 HS_PBIAS VDD VDD pfet_03v3 ad=8.8p pd=40.88u as=8.8p ps=40.88u w=20u l=1u
X823 PULLUP_P_BLEED_0 PULLUP_P_BLEED_1 VSS ppolyf_u_1k r_width=1u r_length=12.5u
X824 a_41684_148611# ESD_RAIL ESD_RAIL VSS nfet_06v0 ad=13p pd=50.52u as=13p ps=50.52u w=50u l=0.7u
X825 PULLUP_N_CONTROL_S VDD VSS VSS nfet_03v3 ad=1.76p pd=8.88u as=1.76p ps=8.88u w=4u l=0.28u
X826 a_41684_160275# a_41684_148611# a_41684_148611# VSS nfet_06v0 ad=13p pd=50.52u as=13p ps=50.52u w=50u l=0.7u
X827 ESD_RAIL a_42245_90628# VSS VSS nfet_06v0 ad=13p pd=50.52u as=13p ps=50.52u w=50u l=0.7u
X828 a_41684_148611# ESD_RAIL ESD_RAIL VSS nfet_06v0 ad=13p pd=50.52u as=13p ps=50.52u w=50u l=0.7u
X829 ESD_RAIL ESD_RAIL a_41684_148611# VSS nfet_06v0 ad=13p pd=50.52u as=13p ps=50.52u w=50u l=0.7u
X830 a_41684_148611# a_41684_148611# a_41684_160275# VSS nfet_06v0 ad=13p pd=50.52u as=13p ps=50.52u w=50u l=0.7u
X831 a_41684_148611# a_41684_148611# a_41684_160275# VSS nfet_06v0 ad=13p pd=50.52u as=13p ps=50.52u w=50u l=0.7u
X832 VDD FS_N_GATE FS_N_WELL FS_N_WELL pfet_03v3 ad=6.16p pd=28.88u as=6.16p ps=28.88u w=14u l=0.28u
X833 PULLUP_P_BLEED_6 PULLUP_P_GATE VSS ppolyf_u_1k r_width=1u r_length=12.5u
X834 a_41684_160275# a_41684_148611# a_41684_148611# VSS nfet_06v0 ad=13p pd=50.52u as=13p ps=50.52u w=50u l=0.7u
X835 ESD_RAIL ESD_RAIL a_41684_148611# VSS nfet_06v0 ad=13p pd=50.52u as=13p ps=50.52u w=50u l=0.7u
X836 a_41684_160275# a_41684_148611# a_41684_148611# VSS nfet_06v0 ad=13p pd=50.52u as=13p ps=50.52u w=50u l=0.7u
X837 a_41684_148611# ESD_RAIL ESD_RAIL VSS nfet_06v0 ad=13p pd=50.52u as=13p ps=50.52u w=50u l=0.7u
X838 HS_P_0 HS_P PAD_P VSS nfet_06v0 ad=8.8p pd=40.88u as=8.8p ps=40.88u w=20u l=0.7u
X839 VDD FS_N_GATE FS_N_WELL FS_N_WELL pfet_03v3 ad=6.16p pd=28.88u as=6.16p ps=28.88u w=14u l=0.28u
X840 FS_P_OUT FS_P_GATE FS_P_WELL FS_P_WELL pfet_03v3 ad=6.16p pd=28.88u as=6.16p ps=28.88u w=14u l=0.28u
X841 a_41684_148611# a_41684_148611# a_41684_160275# VSS nfet_06v0 ad=13p pd=50.52u as=13p ps=50.52u w=50u l=0.7u
X842 a_41684_148611# a_41684_148611# a_41684_160275# VSS nfet_06v0 ad=13p pd=50.52u as=13p ps=50.52u w=50u l=0.7u
D19 PAD_N ESD_RAIL diode_pd2nw_06v0 pj=51.8u area=22.5p
X843 a_41684_148611# ESD_RAIL ESD_RAIL VSS nfet_06v0 ad=13p pd=50.52u as=13p ps=50.52u w=50u l=0.7u
X844 ESD_RAIL ESD_RAIL a_41684_148611# VSS nfet_06v0 ad=13p pd=50.52u as=13p ps=50.52u w=50u l=0.7u
X845 a_41684_160275# a_41684_148611# a_41684_148611# VSS nfet_06v0 ad=13p pd=50.52u as=13p ps=50.52u w=50u l=0.7u
X846 a_41684_148611# ESD_RAIL ESD_RAIL VSS nfet_06v0 ad=13p pd=50.52u as=13p ps=50.52u w=50u l=0.7u
X847 PAD_P BYPASS_ENABLE RX_P VSS nfet_06v0 ad=8.8p pd=40.88u as=8.8p ps=40.88u w=20u l=0.7u
X848 ESD_RAIL ESD_RAIL a_41684_148611# VSS nfet_06v0 ad=13p pd=50.52u as=13p ps=50.52u w=50u l=0.7u
X849 VDD FS_N_GATE FS_N_WELL FS_N_WELL pfet_03v3 ad=6.16p pd=28.88u as=6.16p ps=28.88u w=14u l=0.28u
X850 a_41684_148611# a_41684_148611# a_41684_160275# VSS nfet_06v0 ad=13p pd=50.52u as=13p ps=50.52u w=50u l=0.7u
X851 a_41684_160275# a_41684_148611# a_41684_148611# VSS nfet_06v0 ad=13p pd=50.52u as=13p ps=50.52u w=50u l=0.7u
X852 FS_P_OUT FS_P_GATE FS_P_WELL FS_P_WELL pfet_03v3 ad=6.16p pd=28.88u as=6.16p ps=28.88u w=14u l=0.28u
X853 a_41684_148611# ESD_RAIL ESD_RAIL VSS nfet_06v0 ad=13p pd=50.52u as=13p ps=50.52u w=50u l=0.7u
X854 a_41005_133505# a_53878_133785# ESD_RAIL ppolyf_u r_width=0.8u r_length=63.855u
X855 a_41684_148611# ESD_RAIL ESD_RAIL VSS nfet_06v0 ad=13p pd=50.52u as=13p ps=50.52u w=50u l=0.7u
X856 a_41684_160275# a_41684_148611# a_41684_148611# VSS nfet_06v0 ad=13p pd=50.52u as=13p ps=50.52u w=50u l=0.7u
X857 a_41684_148611# a_41684_148611# a_41684_160275# VSS nfet_06v0 ad=13p pd=50.52u as=13p ps=50.52u w=50u l=0.7u
X858 VSS a_41684_160275# a_41684_160275# VSS nfet_06v0 ad=13p pd=50.52u as=13p ps=50.52u w=50u l=0.7u
X859 ESD_RAIL ESD_RAIL a_41684_148611# VSS nfet_06v0 ad=13p pd=50.52u as=13p ps=50.52u w=50u l=0.7u
X860 a_41684_148611# a_41684_148611# a_41684_160275# VSS nfet_06v0 ad=13p pd=50.52u as=13p ps=50.52u w=50u l=0.7u
X861 a_41684_160275# a_41684_148611# a_41684_148611# VSS nfet_06v0 ad=22p pd=0.10088m as=13p ps=50.52u w=50u l=0.7u
X862 VDD PULLUP_P_GATE PULLUP_P_WELL PULLUP_P_WELL pfet_03v3 ad=8.8p pd=40.88u as=8.8p ps=40.88u w=20u l=0.28u
X863 ESD_RAIL a_42245_90628# VSS VSS nfet_06v0 ad=13p pd=50.52u as=13p ps=50.52u w=50u l=0.7u
X864 a_41684_160275# a_41684_148611# a_41684_148611# VSS nfet_06v0 ad=13p pd=50.52u as=13p ps=50.52u w=50u l=0.7u
X865 a_41684_160275# a_41684_148611# a_41684_148611# VSS nfet_06v0 ad=13p pd=50.52u as=13p ps=50.52u w=50u l=0.7u
X866 PAD_P BYPASS_ENABLE RX_P VSS nfet_06v0 ad=8.8p pd=40.88u as=8.8p ps=40.88u w=20u l=0.7u
X867 VSS a_41684_160275# a_41684_160275# VSS nfet_06v0 ad=13p pd=50.52u as=13p ps=50.52u w=50u l=0.7u
X868 VDD FS_N_GATE FS_N_WELL FS_N_WELL pfet_03v3 ad=6.16p pd=28.88u as=6.16p ps=28.88u w=14u l=0.28u
X869 a_41684_148611# a_41684_148611# a_41684_160275# VSS nfet_06v0 ad=13p pd=50.52u as=13p ps=50.52u w=50u l=0.7u
X870 ESD_RAIL a_42245_90628# VSS VSS nfet_06v0 ad=13p pd=50.52u as=13p ps=50.52u w=50u l=0.7u
X871 a_41684_160275# a_41684_148611# a_41684_148611# VSS nfet_06v0 ad=13p pd=50.52u as=13p ps=50.52u w=50u l=0.7u
X872 a_41684_160275# a_41684_148611# a_41684_148611# VSS nfet_06v0 ad=13p pd=50.52u as=13p ps=50.52u w=50u l=0.7u
X873 a_41684_148611# a_41684_148611# a_41684_160275# VSS nfet_06v0 ad=13p pd=50.52u as=13p ps=50.52u w=50u l=0.7u
X874 VSS a_42245_90628# ESD_RAIL VSS nfet_06v0 ad=13p pd=50.52u as=13p ps=50.52u w=50u l=0.7u
X875 a_41684_148611# a_41684_148611# a_41684_160275# VSS nfet_06v0 ad=13p pd=50.52u as=13p ps=50.52u w=50u l=0.7u
X876 a_41684_160275# a_41684_148611# a_41684_148611# VSS nfet_06v0 ad=13p pd=50.52u as=13p ps=50.52u w=50u l=0.7u
X877 HS_P_5 HS_PBIAS VDD VDD pfet_03v3 ad=8.8p pd=40.88u as=8.8p ps=40.88u w=20u l=1u
X878 ESD_RAIL a_44789_117064# a_42245_90628# ESD_RAIL pfet_06v0 ad=1.3p pd=5.52u as=1.3p ps=5.52u w=5u l=0.7u
X879 a_41684_160275# a_41684_160275# VSS VSS nfet_06v0 ad=13p pd=50.52u as=13p ps=50.52u w=50u l=0.7u
D20 VSS PULLDOWN_P diode_nd2ps_03v3 pj=4.92u area=1.5129p
X880 a_41684_148611# a_41684_148611# a_41684_160275# VSS nfet_06v0 ad=13p pd=50.52u as=13p ps=50.52u w=50u l=0.7u
X881 VSS a_42245_90628# ESD_RAIL VSS nfet_06v0 ad=13p pd=50.52u as=13p ps=50.52u w=50u l=0.7u
X882 a_41684_160275# a_41684_148611# a_41684_148611# VSS nfet_06v0 ad=13p pd=50.52u as=13p ps=50.52u w=50u l=0.7u
X883 a_41684_148611# a_41684_148611# a_41684_160275# VSS nfet_06v0 ad=13p pd=50.52u as=13p ps=50.52u w=50u l=0.7u
X884 a_41684_160275# a_41684_160275# VSS VSS nfet_06v0 ad=13p pd=50.52u as=13p ps=50.52u w=50u l=0.7u
X885 a_41684_160275# a_41684_148611# a_41684_148611# VSS nfet_06v0 ad=13p pd=50.52u as=13p ps=50.52u w=50u l=0.7u
X886 FS_P_OUT FS_P_GATE FS_P_WELL FS_P_WELL pfet_03v3 ad=6.16p pd=28.88u as=6.16p ps=28.88u w=14u l=0.28u
X887 HS_P_8 HS_P PAD_P VSS nfet_06v0 ad=8.8p pd=40.88u as=8.8p ps=40.88u w=20u l=0.7u
X888 a_41684_148611# a_41684_148611# a_41684_160275# VSS nfet_06v0 ad=13p pd=50.52u as=13p ps=50.52u w=50u l=0.7u
X889 a_41684_148611# a_41684_148611# a_41684_160275# VSS nfet_06v0 ad=13p pd=50.52u as=13p ps=50.52u w=50u l=0.7u
X890 a_41684_160275# a_41684_160275# VSS VSS nfet_06v0 ad=13p pd=50.52u as=13p ps=50.52u w=50u l=0.7u
X891 a_44789_117064# a_43813_117064# VSS VSS nfet_06v0 ad=1.3p pd=5.52u as=1.3p ps=5.52u w=5u l=0.7u
X892 a_41684_160275# a_41684_148611# a_41684_148611# VSS nfet_06v0 ad=13p pd=50.52u as=13p ps=50.52u w=50u l=0.7u
X893 FS_P_OUT FS_P_GATE FS_P_WELL FS_P_WELL pfet_03v3 ad=6.16p pd=28.88u as=6.16p ps=28.88u w=14u l=0.28u
X894 a_41684_148611# a_41684_148611# a_41684_160275# VSS nfet_06v0 ad=13p pd=50.52u as=13p ps=50.52u w=50u l=0.7u
X895 a_41684_148611# a_41684_148611# a_41684_160275# VSS nfet_06v0 ad=13p pd=50.52u as=13p ps=50.52u w=50u l=0.7u
X896 a_41684_160275# a_41684_148611# a_41684_148611# VSS nfet_06v0 ad=13p pd=50.52u as=13p ps=50.52u w=50u l=0.7u
X897 VSS a_41684_160275# a_41684_160275# VSS nfet_06v0 ad=13p pd=50.52u as=13p ps=50.52u w=50u l=0.7u
X898 a_41684_148611# ESD_RAIL ESD_RAIL VSS nfet_06v0 ad=13p pd=50.52u as=13p ps=50.52u w=50u l=0.7u
X899 a_41684_148611# a_41684_148611# a_41684_160275# VSS nfet_06v0 ad=13p pd=50.52u as=13p ps=50.52u w=50u l=0.7u
D21 VSS ESD_RAIL diode_nd2ps_06v0 pj=82u area=40p
X900 a_41684_160275# a_41684_148611# a_41684_148611# VSS nfet_06v0 ad=13p pd=50.52u as=13p ps=50.52u w=50u l=0.7u
X901 VSS a_41684_160275# a_41684_160275# VSS nfet_06v0 ad=13p pd=50.52u as=13p ps=50.52u w=50u l=0.7u
X902 VSS a_41684_160275# a_41684_160275# VSS nfet_06v0 ad=13p pd=50.52u as=13p ps=50.52u w=50u l=0.7u
X903 a_41684_148611# ESD_RAIL ESD_RAIL VSS nfet_06v0 ad=13p pd=50.52u as=13p ps=50.52u w=50u l=0.7u
X904 DIV_LOW_N DIV_ENABLE VSS VSS nfet_03v3 ad=8.8p pd=40.88u as=8.8p ps=40.88u w=20u l=0.28u
X905 a_41684_148611# a_41684_148611# a_41684_160275# VSS nfet_06v0 ad=13p pd=50.52u as=13p ps=50.52u w=50u l=0.7u
X906 VSS a_42245_90628# ESD_RAIL VSS nfet_06v0 ad=13p pd=50.52u as=13p ps=50.52u w=50u l=0.7u
X907 VSS a_42245_90628# ESD_RAIL VSS nfet_06v0 ad=13p pd=50.52u as=13p ps=50.52u w=50u l=0.7u
X908 VDD FS_N_GATE FS_N_WELL FS_N_WELL pfet_03v3 ad=6.16p pd=28.88u as=6.16p ps=28.88u w=14u l=0.28u
X909 a_41684_160275# a_41684_148611# a_41684_148611# VSS nfet_06v0 ad=13p pd=50.52u as=13p ps=50.52u w=50u l=0.7u
X910 VSS a_42245_90628# ESD_RAIL VSS nfet_06v0 ad=13p pd=50.52u as=13p ps=50.52u w=50u l=0.7u
X911 a_41684_160275# a_41684_148611# a_41684_148611# VSS nfet_06v0 ad=13p pd=50.52u as=13p ps=50.52u w=50u l=0.7u
X912 a_42245_90628# VSS VSS ppolyf_u_1k_6p0 r_width=1u r_length=99.24u
X913 ESD_RAIL ESD_RAIL a_41684_148611# VSS nfet_06v0 ad=13p pd=50.52u as=13p ps=50.52u w=50u l=0.7u
X914 a_41684_148611# a_41684_148611# a_41684_160275# VSS nfet_06v0 ad=13p pd=50.52u as=13p ps=50.52u w=50u l=0.7u
X915 VSS a_42245_90628# ESD_RAIL VSS nfet_06v0 ad=13p pd=50.52u as=13p ps=50.52u w=50u l=0.7u
X916 ESD_RAIL a_42245_90628# VSS VSS nfet_06v0 ad=13p pd=50.52u as=13p ps=50.52u w=50u l=0.7u
X917 a_41684_160275# a_41684_148611# a_41684_148611# VSS nfet_06v0 ad=13p pd=50.52u as=13p ps=50.52u w=50u l=0.7u
X918 a_41684_160275# a_41684_148611# a_41684_148611# VSS nfet_06v0 ad=13p pd=50.52u as=13p ps=50.52u w=50u l=0.7u
X919 HS_P_7 HS_P PAD_P VSS nfet_06v0 ad=8.8p pd=40.88u as=8.8p ps=40.88u w=20u l=0.7u
X920 TERM_GATE_P_BLEED_0 TERM_GATE_P_BLEED_1 VSS ppolyf_u_1k r_width=1u r_length=12.5u
X921 a_41684_160275# a_41684_160275# VSS VSS nfet_06v0 ad=13p pd=50.52u as=13p ps=50.52u w=50u l=0.7u
X922 a_41684_160275# a_41684_160275# VSS VSS nfet_06v0 ad=13p pd=50.52u as=13p ps=50.52u w=50u l=0.7u
X923 ESD_RAIL ESD_RAIL a_41684_148611# VSS nfet_06v0 ad=13p pd=50.52u as=13p ps=50.52u w=50u l=0.7u
X924 a_41684_160275# a_41684_148611# a_41684_148611# VSS nfet_06v0 ad=13p pd=50.52u as=13p ps=50.52u w=50u l=0.7u
X925 a_41684_160275# a_41684_160275# VSS VSS nfet_06v0 ad=13p pd=50.52u as=13p ps=50.52u w=50u l=0.7u
X926 ESD_RAIL a_42245_90628# VSS VSS nfet_06v0 ad=22p pd=0.10088m as=13p ps=50.52u w=50u l=0.7u
X927 a_41005_133505# a_53878_133225# ESD_RAIL ppolyf_u r_width=0.8u r_length=63.855u
X928 a_41684_160275# a_41684_160275# VSS VSS nfet_06v0 ad=13p pd=50.52u as=13p ps=50.52u w=50u l=0.7u
X929 ESD_RAIL ESD_RAIL a_41684_148611# VSS nfet_06v0 ad=13p pd=50.52u as=13p ps=50.52u w=50u l=0.7u
X930 FS_P_BLEED_5 FS_P_BLEED_6 VSS ppolyf_u_1k r_width=1u r_length=12.5u
X931 a_41684_160275# a_41684_148611# a_41684_148611# VSS nfet_06v0 ad=13p pd=50.52u as=13p ps=50.52u w=50u l=0.7u
X932 PULLUP_P_OUT PULLUP_P_GATE PULLUP_P_WELL PULLUP_P_WELL pfet_03v3 ad=8.8p pd=40.88u as=8.8p ps=40.88u w=20u l=0.28u
X933 VDD FS_P_GATE FS_P_WELL FS_P_WELL pfet_03v3 ad=6.16p pd=28.88u as=6.16p ps=28.88u w=14u l=0.28u
X934 VSS a_41684_160275# a_41684_160275# VSS nfet_06v0 ad=13p pd=50.52u as=13p ps=50.52u w=50u l=0.7u
X935 VSS a_41684_160275# a_41684_160275# VSS nfet_06v0 ad=13p pd=50.52u as=13p ps=50.52u w=50u l=0.7u
X936 a_41684_160275# a_41684_160275# VSS VSS nfet_06v0 ad=13p pd=50.52u as=13p ps=50.52u w=50u l=0.7u
X937 DIV_P DIV_LOW_P VSS ppolyf_u_1k r_width=1u r_length=2u
X938 a_41684_148611# ESD_RAIL ESD_RAIL VSS nfet_06v0 ad=13p pd=50.52u as=13p ps=50.52u w=50u l=0.7u
X939 TERM_N_R TERM_GATE_N TERM_VCM VSS nfet_03v3 ad=8.8p pd=40.88u as=8.8p ps=40.88u w=20u l=0.28u
X940 VSS a_41684_160275# a_41684_160275# VSS nfet_06v0 ad=13p pd=50.52u as=13p ps=50.52u w=50u l=0.7u
X941 a_41684_148611# ESD_RAIL ESD_RAIL VSS nfet_06v0 ad=13p pd=50.52u as=13p ps=50.52u w=50u l=0.7u
X942 HS_P_1 HS_P PAD_P VSS nfet_06v0 ad=8.8p pd=40.88u as=8.8p ps=40.88u w=20u l=0.7u
X943 VSS a_41684_160275# a_41684_160275# VSS nfet_06v0 ad=13p pd=50.52u as=13p ps=50.52u w=50u l=0.7u
X944 a_41684_160275# a_41684_160275# VSS VSS nfet_06v0 ad=13p pd=50.52u as=13p ps=50.52u w=50u l=0.7u
X945 VSS a_41684_160275# a_41684_160275# VSS nfet_06v0 ad=13p pd=50.52u as=13p ps=50.52u w=50u l=0.7u
X946 TERM_P_R TERM_GATE_P TERM_VCM VSS nfet_03v3 ad=8.8p pd=40.88u as=8.8p ps=40.88u w=20u l=0.28u
X947 a_41684_148611# ESD_RAIL ESD_RAIL VSS nfet_06v0 ad=13p pd=50.52u as=13p ps=50.52u w=50u l=0.7u
X948 HS_N_5 HS_PBIAS VDD VDD pfet_03v3 ad=8.8p pd=40.88u as=8.8p ps=40.88u w=20u l=1u
X949 VSS a_41684_160275# a_41684_160275# VSS nfet_06v0 ad=13p pd=50.52u as=13p ps=50.52u w=50u l=0.7u
X950 a_41684_148611# a_41684_148611# a_41684_160275# VSS nfet_06v0 ad=13p pd=50.52u as=13p ps=50.52u w=50u l=0.7u
X951 PAD_P TERM_P_R VSS ppolyf_u r_width=16u r_length=1.3u
X952 TERM_N_R TERM_GATE_N TERM_VCM VSS nfet_03v3 ad=8.8p pd=40.88u as=8.8p ps=40.88u w=20u l=0.28u
X953 VSS a_41684_160275# a_41684_160275# VSS nfet_06v0 ad=13p pd=50.52u as=13p ps=50.52u w=50u l=0.7u
X954 HS_P_4 HS_P PAD_P VSS nfet_06v0 ad=8.8p pd=40.88u as=8.8p ps=40.88u w=20u l=0.7u
X955 a_41684_160275# a_41684_160275# VSS VSS nfet_06v0 ad=13p pd=50.52u as=13p ps=50.52u w=50u l=0.7u
X956 a_41684_160275# a_41684_148611# a_41684_148611# VSS nfet_06v0 ad=13p pd=50.52u as=13p ps=50.52u w=50u l=0.7u
X957 VSS a_42245_90628# ESD_RAIL VSS nfet_06v0 ad=13p pd=50.52u as=13p ps=50.52u w=50u l=0.7u
X958 FS_P_GATE VDD FS_P_WELL FS_P_WELL pfet_03v3 ad=1.76p pd=8.88u as=1.76p ps=8.88u w=4u l=0.28u
X959 a_41684_148611# a_41684_148611# a_41684_160275# VSS nfet_06v0 ad=13p pd=50.52u as=13p ps=50.52u w=50u l=0.7u
X960 FS_N_BLEED_2 FS_N_BLEED_3 VSS ppolyf_u_1k r_width=1u r_length=12.5u
X961 a_41684_160275# a_41684_160275# VSS VSS nfet_06v0 ad=13p pd=50.52u as=13p ps=50.52u w=50u l=0.7u
X962 ESD_RAIL ESD_RAIL a_41684_148611# VSS nfet_06v0 ad=13p pd=50.52u as=13p ps=50.52u w=50u l=0.7u
X963 VSS a_41684_160275# a_41684_160275# VSS nfet_06v0 ad=13p pd=50.52u as=13p ps=50.52u w=50u l=0.7u
X964 a_41684_160275# a_41684_148611# a_41684_148611# VSS nfet_06v0 ad=13p pd=50.52u as=13p ps=50.52u w=50u l=0.7u
X965 ESD_RAIL ESD_RAIL a_41684_148611# VSS nfet_06v0 ad=13p pd=50.52u as=13p ps=50.52u w=50u l=0.7u
X966 FS_N_GATE FS_HIGH_N FS_N_WELL FS_N_WELL pfet_03v3 ad=1.76p pd=8.88u as=1.76p ps=8.88u w=4u l=0.28u
X967 DIV_N DIV_LOW_N VSS ppolyf_u_1k r_width=1u r_length=2u
X968 TERM_GATE_N TERM_GATE_N_BLEED_0 VSS ppolyf_u_1k r_width=1u r_length=12.5u
X969 ESD_RAIL a_44789_117064# a_42245_90628# ESD_RAIL pfet_06v0 ad=1.3p pd=5.52u as=1.3p ps=5.52u w=5u l=0.7u
X970 PULLUP_N_WELL PULLUP_N_BLEED_0 VSS ppolyf_u_1k r_width=1u r_length=12.5u
X971 FS_P_BLEED_3 FS_P_BLEED_4 VSS ppolyf_u_1k r_width=1u r_length=12.5u
X972 a_41684_160275# a_41684_160275# VSS VSS nfet_06v0 ad=13p pd=50.52u as=13p ps=50.52u w=50u l=0.7u
X973 ESD_RAIL a_42245_90628# VSS VSS nfet_06v0 ad=13p pd=50.52u as=13p ps=50.52u w=50u l=0.7u
X974 ESD_RAIL ESD_RAIL a_41684_148611# VSS nfet_06v0 ad=13p pd=50.52u as=13p ps=50.52u w=50u l=0.7u
X975 PULLUP_P_BLEED_2 PULLUP_P_BLEED_3 VSS ppolyf_u_1k r_width=1u r_length=12.5u
X976 PULLUP_P_OUT PULLUP_P_GATE PULLUP_P_WELL PULLUP_P_WELL pfet_03v3 ad=8.8p pd=40.88u as=8.8p ps=40.88u w=20u l=0.28u
X977 VDD FS_P_GATE FS_P_WELL FS_P_WELL pfet_03v3 ad=6.16p pd=28.88u as=6.16p ps=28.88u w=14u l=0.28u
X978 VSS a_41684_160275# a_41684_160275# VSS nfet_06v0 ad=13p pd=50.52u as=13p ps=50.52u w=50u l=0.7u
X979 ESD_RAIL a_53878_134345# ESD_RAIL ppolyf_u r_width=0.8u r_length=63.855u
X980 ESD_RAIL ESD_RAIL a_41684_148611# VSS nfet_06v0 ad=13p pd=50.52u as=13p ps=50.52u w=50u l=0.7u
X981 FS_N_BLEED_4 FS_N_BLEED_5 VSS ppolyf_u_1k r_width=1u r_length=12.5u
D22 VSS PAD_N diode_nd2ps_06v0 pj=51.8u area=22.5p
X982 a_41684_160275# a_41684_148611# a_41684_148611# VSS nfet_06v0 ad=13p pd=50.52u as=13p ps=50.52u w=50u l=0.7u
X983 VSS a_41684_160275# a_41684_160275# VSS nfet_06v0 ad=13p pd=50.52u as=13p ps=50.52u w=50u l=0.7u
D23 PAD_P ESD_RAIL diode_pd2nw_06v0 pj=51.8u area=22.5p
X984 a_41684_148611# ESD_RAIL ESD_RAIL VSS nfet_06v0 ad=13p pd=50.52u as=13p ps=50.52u w=50u l=0.7u
X985 a_41684_160275# a_41684_160275# VSS VSS nfet_06v0 ad=13p pd=50.52u as=13p ps=50.52u w=50u l=0.7u
X986 a_41684_148611# a_41684_148611# a_41684_160275# VSS nfet_06v0 ad=13p pd=50.52u as=13p ps=50.52u w=50u l=0.7u
X987 HS_P_13 HS_P PAD_P VSS nfet_06v0 ad=8.8p pd=40.88u as=8.8p ps=40.88u w=20u l=0.7u
X988 ESD_RAIL ESD_RAIL a_41684_148611# VSS nfet_06v0 ad=13p pd=50.52u as=13p ps=50.52u w=50u l=0.7u
X989 a_41684_148611# ESD_RAIL ESD_RAIL VSS nfet_06v0 ad=13p pd=50.52u as=13p ps=50.52u w=50u l=0.7u
X990 a_41684_160275# a_41684_148611# a_41684_148611# VSS nfet_06v0 ad=13p pd=50.52u as=13p ps=50.52u w=50u l=0.7u
X991 a_41684_148611# a_41684_148611# a_41684_160275# VSS nfet_06v0 ad=13p pd=50.52u as=13p ps=50.52u w=50u l=0.7u
X992 a_41684_160275# a_41684_148611# a_41684_148611# VSS nfet_06v0 ad=13p pd=50.52u as=13p ps=50.52u w=50u l=0.7u
X993 a_41684_148611# ESD_RAIL ESD_RAIL VSS nfet_06v0 ad=13p pd=50.52u as=13p ps=50.52u w=50u l=0.7u
X994 VSS a_41684_160275# a_41684_160275# VSS nfet_06v0 ad=13p pd=50.52u as=13p ps=50.52u w=50u l=0.7u
X995 a_41684_148611# ESD_RAIL ESD_RAIL VSS nfet_06v0 ad=13p pd=50.52u as=13p ps=50.52u w=50u l=0.7u
X996 VDD PULLUP_N_GATE PULLUP_N_WELL PULLUP_N_WELL pfet_03v3 ad=8.8p pd=40.88u as=8.8p ps=40.88u w=20u l=0.28u
X997 HS_N_3 HS_PBIAS VDD VDD pfet_03v3 ad=8.8p pd=40.88u as=8.8p ps=40.88u w=20u l=1u
X998 a_41684_160275# a_41684_160275# VSS VSS nfet_06v0 ad=13p pd=50.52u as=13p ps=50.52u w=50u l=0.7u
X999 a_41684_148611# a_41684_148611# a_41684_160275# VSS nfet_06v0 ad=13p pd=50.52u as=22p ps=0.10088m w=50u l=0.7u
X1000 ESD_RAIL ESD_RAIL a_41684_148611# VSS nfet_06v0 ad=13p pd=50.52u as=13p ps=50.52u w=50u l=0.7u
X1001 a_41684_148611# ESD_RAIL ESD_RAIL VSS nfet_06v0 ad=13p pd=50.52u as=13p ps=50.52u w=50u l=0.7u
X1002 a_41684_148611# ESD_RAIL ESD_RAIL VSS nfet_06v0 ad=13p pd=50.52u as=13p ps=50.52u w=50u l=0.7u
X1003 VDD FS_P_GATE FS_P_WELL FS_P_WELL pfet_03v3 ad=6.16p pd=28.88u as=6.16p ps=28.88u w=14u l=0.28u
X1004 a_41684_148611# ESD_RAIL ESD_RAIL VSS nfet_06v0 ad=13p pd=50.52u as=13p ps=50.52u w=50u l=0.7u
X1005 ESD_RAIL ESD_RAIL a_41684_148611# VSS nfet_06v0 ad=13p pd=50.52u as=13p ps=50.52u w=50u l=0.7u
X1006 a_41684_160275# a_41684_148611# a_41684_148611# VSS nfet_06v0 ad=13p pd=50.52u as=13p ps=50.52u w=50u l=0.7u
X1007 VSS a_42245_90628# ESD_RAIL VSS nfet_06v0 ad=13p pd=50.52u as=22p ps=0.10088m w=50u l=0.7u
X1008 a_41684_148611# a_41684_148611# a_41684_160275# VSS nfet_06v0 ad=13p pd=50.52u as=13p ps=50.52u w=50u l=0.7u
X1009 a_41684_148611# a_41684_148611# a_41684_160275# VSS nfet_06v0 ad=13p pd=50.52u as=13p ps=50.52u w=50u l=0.7u
X1010 ESD_RAIL ESD_RAIL a_41684_148611# VSS nfet_06v0 ad=13p pd=50.52u as=13p ps=50.52u w=50u l=0.7u
X1011 VDD FS_P_GATE FS_P_WELL FS_P_WELL pfet_03v3 ad=6.16p pd=28.88u as=6.16p ps=28.88u w=14u l=0.28u
X1012 a_41684_160275# a_41684_160275# VSS VSS nfet_06v0 ad=13p pd=50.52u as=13p ps=50.52u w=50u l=0.7u
X1013 VSS a_41684_160275# a_41684_160275# VSS nfet_06v0 ad=13p pd=50.52u as=13p ps=50.52u w=50u l=0.7u
X1014 a_41684_160275# a_41684_148611# a_41684_148611# VSS nfet_06v0 ad=13p pd=50.52u as=13p ps=50.52u w=50u l=0.7u
X1015 a_41684_148611# ESD_RAIL ESD_RAIL VSS nfet_06v0 ad=13p pd=50.52u as=13p ps=50.52u w=50u l=0.7u
X1016 a_41684_148611# a_41684_148611# a_41684_160275# VSS nfet_06v0 ad=13p pd=50.52u as=13p ps=50.52u w=50u l=0.7u
X1017 VSS a_42245_90628# ESD_RAIL VSS nfet_06v0 ad=13p pd=50.52u as=13p ps=50.52u w=50u l=0.7u
X1018 ESD_RAIL a_42245_90628# VSS VSS nfet_06v0 ad=13p pd=50.52u as=13p ps=50.52u w=50u l=0.7u
X1019 HS_N_12 HS_N PAD_N VSS nfet_06v0 ad=8.8p pd=40.88u as=8.8p ps=40.88u w=20u l=0.7u
X1020 ESD_RAIL ESD_RAIL a_41684_148611# VSS nfet_06v0 ad=13p pd=50.52u as=13p ps=50.52u w=50u l=0.7u
X1021 ESD_RAIL a_42245_90628# VSS VSS nfet_06v0 ad=13p pd=50.52u as=13p ps=50.52u w=50u l=0.7u
D24 VSS PAD_P diode_nd2ps_06v0 pj=51.8u area=22.5p
X1022 a_41684_148611# a_41684_148611# a_41684_160275# VSS nfet_06v0 ad=13p pd=50.52u as=13p ps=50.52u w=50u l=0.7u
X1023 a_41684_148611# ESD_RAIL ESD_RAIL VSS nfet_06v0 ad=13p pd=50.52u as=13p ps=50.52u w=50u l=0.7u
X1024 PAD_N BYPASS_ENABLE RX_N VSS nfet_06v0 ad=8.8p pd=40.88u as=8.8p ps=40.88u w=20u l=0.7u
X1025 ESD_RAIL a_42245_90628# VSS VSS nfet_06v0 ad=13p pd=50.52u as=13p ps=50.52u w=50u l=0.7u
X1026 FS_N_OUT FS_N_GATE FS_N_WELL FS_N_WELL pfet_03v3 ad=6.16p pd=28.88u as=6.16p ps=28.88u w=14u l=0.28u
X1027 a_41684_160275# a_41684_148611# a_41684_148611# VSS nfet_06v0 ad=13p pd=50.52u as=13p ps=50.52u w=50u l=0.7u
X1028 VSS a_42245_90628# ESD_RAIL VSS nfet_06v0 ad=13p pd=50.52u as=13p ps=50.52u w=50u l=0.7u
X1029 VSS a_41684_160275# a_41684_160275# VSS nfet_06v0 ad=13p pd=50.52u as=13p ps=50.52u w=50u l=0.7u
X1030 a_41684_148611# ESD_RAIL ESD_RAIL VSS nfet_06v0 ad=13p pd=50.52u as=13p ps=50.52u w=50u l=0.7u
X1031 a_41684_160275# a_41684_160275# VSS VSS nfet_06v0 ad=13p pd=50.52u as=13p ps=50.52u w=50u l=0.7u
X1032 a_41684_148611# a_41684_148611# a_41684_160275# VSS nfet_06v0 ad=13p pd=50.52u as=13p ps=50.52u w=50u l=0.7u
X1033 ESD_RAIL ESD_RAIL a_41684_148611# VSS nfet_06v0 ad=13p pd=50.52u as=13p ps=50.52u w=50u l=0.7u
X1034 FS_N_OUT FS_N_GATE FS_N_WELL FS_N_WELL pfet_03v3 ad=6.16p pd=28.88u as=6.16p ps=28.88u w=14u l=0.28u
X1035 a_41684_160275# a_41684_148611# a_41684_148611# VSS nfet_06v0 ad=13p pd=50.52u as=13p ps=50.52u w=50u l=0.7u
X1036 a_41684_160275# a_41684_148611# a_41684_148611# VSS nfet_06v0 ad=13p pd=50.52u as=13p ps=50.52u w=50u l=0.7u
X1037 a_41684_148611# ESD_RAIL ESD_RAIL VSS nfet_06v0 ad=13p pd=50.52u as=13p ps=50.52u w=50u l=0.7u
X1038 HS_P_9 HS_P PAD_P VSS nfet_06v0 ad=8.8p pd=40.88u as=8.8p ps=40.88u w=20u l=0.7u
X1039 VDD PULLUP_N_GATE PULLUP_N_WELL PULLUP_N_WELL pfet_03v3 ad=8.8p pd=40.88u as=8.8p ps=40.88u w=20u l=0.28u
X1040 FS_N_OUT FS_N_GATE FS_N_WELL FS_N_WELL pfet_03v3 ad=6.16p pd=28.88u as=6.16p ps=28.88u w=14u l=0.28u
X1041 VDD FS_P_GATE FS_P_WELL FS_P_WELL pfet_03v3 ad=6.16p pd=28.88u as=6.16p ps=28.88u w=14u l=0.28u
X1042 a_41684_148611# a_41684_148611# a_41684_160275# VSS nfet_06v0 ad=13p pd=50.52u as=13p ps=50.52u w=50u l=0.7u
X1043 ESD_RAIL ESD_RAIL a_41684_148611# VSS nfet_06v0 ad=13p pd=50.52u as=13p ps=50.52u w=50u l=0.7u
X1044 a_41684_160275# a_41684_148611# a_41684_148611# VSS nfet_06v0 ad=13p pd=50.52u as=13p ps=50.52u w=50u l=0.7u
X1045 a_41684_148611# a_41684_148611# a_41684_160275# VSS nfet_06v0 ad=13p pd=50.52u as=13p ps=50.52u w=50u l=0.7u
X1046 a_41684_148611# a_41684_148611# a_41684_160275# VSS nfet_06v0 ad=13p pd=50.52u as=13p ps=50.52u w=50u l=0.7u
X1047 FS_N_OUT FS_N_GATE FS_N_WELL FS_N_WELL pfet_03v3 ad=6.16p pd=28.88u as=6.16p ps=28.88u w=14u l=0.28u
X1048 a_41684_160275# a_41684_148611# a_41684_148611# VSS nfet_06v0 ad=13p pd=50.52u as=13p ps=50.52u w=50u l=0.7u
X1049 HS_P_2 HS_PBIAS VDD VDD pfet_03v3 ad=8.8p pd=40.88u as=8.8p ps=40.88u w=20u l=1u
X1050 a_41684_148611# a_41684_148611# a_41684_160275# VSS nfet_06v0 ad=13p pd=50.52u as=13p ps=50.52u w=50u l=0.7u
X1051 a_41684_148611# a_41684_148611# a_41684_160275# VSS nfet_06v0 ad=13p pd=50.52u as=13p ps=50.52u w=50u l=0.7u
X1052 ESD_RAIL ESD_RAIL a_41684_148611# VSS nfet_06v0 ad=13p pd=50.52u as=13p ps=50.52u w=50u l=0.7u
X1053 a_41684_160275# a_41684_148611# a_41684_148611# VSS nfet_06v0 ad=13p pd=50.52u as=13p ps=50.52u w=50u l=0.7u
X1054 a_41684_148611# a_41684_148611# a_41684_160275# VSS nfet_06v0 ad=13p pd=50.52u as=13p ps=50.52u w=50u l=0.7u
X1055 HS_P_8 HS_PBIAS VDD VDD pfet_03v3 ad=8.8p pd=40.88u as=8.8p ps=40.88u w=20u l=1u
X1056 a_41684_148611# ESD_RAIL ESD_RAIL VSS nfet_06v0 ad=13p pd=50.52u as=13p ps=50.52u w=50u l=0.7u
X1057 a_41684_148611# a_41684_148611# a_41684_160275# VSS nfet_06v0 ad=13p pd=50.52u as=13p ps=50.52u w=50u l=0.7u
X1058 ESD_RAIL a_41005_131545# a_43813_117064# ESD_RAIL pfet_06v0 ad=1.3p pd=5.52u as=1.3p ps=5.52u w=5u l=0.7u
X1059 VDD FS_P_GATE FS_P_WELL FS_P_WELL pfet_03v3 ad=6.16p pd=28.88u as=6.16p ps=28.88u w=14u l=0.28u
X1060 a_41684_148611# a_41684_148611# a_41684_160275# VSS nfet_06v0 ad=13p pd=50.52u as=13p ps=50.52u w=50u l=0.7u
X1061 a_41684_160275# a_41684_148611# a_41684_148611# VSS nfet_06v0 ad=13p pd=50.52u as=13p ps=50.52u w=50u l=0.7u
X1062 a_41684_160275# a_41684_148611# a_41684_148611# VSS nfet_06v0 ad=13p pd=50.52u as=13p ps=50.52u w=50u l=0.7u
X1063 VDD FS_P_GATE FS_P_WELL FS_P_WELL pfet_03v3 ad=6.16p pd=28.88u as=6.16p ps=28.88u w=14u l=0.28u
X1064 FS_N_OUT FS_N_GATE FS_N_WELL FS_N_WELL pfet_03v3 ad=6.16p pd=28.88u as=6.16p ps=28.88u w=14u l=0.28u
X1065 HS_N_13 HS_PBIAS VDD VDD pfet_03v3 ad=8.8p pd=40.88u as=8.8p ps=40.88u w=20u l=1u
X1066 VSS a_41684_160275# a_41684_160275# VSS nfet_06v0 ad=13p pd=50.52u as=13p ps=50.52u w=50u l=0.7u
X1067 VDD FS_P_GATE FS_P_WELL FS_P_WELL pfet_03v3 ad=6.16p pd=28.88u as=6.16p ps=28.88u w=14u l=0.28u
X1068 a_41684_148611# a_41684_148611# a_41684_160275# VSS nfet_06v0 ad=13p pd=50.52u as=13p ps=50.52u w=50u l=0.7u
X1069 a_41684_148611# a_41684_148611# a_41684_160275# VSS nfet_06v0 ad=13p pd=50.52u as=13p ps=50.52u w=50u l=0.7u
X1070 a_41684_148611# ESD_RAIL ESD_RAIL VSS nfet_06v0 ad=13p pd=50.52u as=13p ps=50.52u w=50u l=0.7u
X1071 PAD_P DIV_P VSS ppolyf_u_1k r_width=1u r_length=2u
X1072 ESD_RAIL ESD_RAIL a_41684_148611# VSS nfet_06v0 ad=13p pd=50.52u as=13p ps=50.52u w=50u l=0.7u
X1073 PULLDOWN_N_R PULLDOWN_N VSS VSS nfet_03v3 ad=3.52p pd=16.88u as=3.52p ps=16.88u w=8u l=0.28u
X1074 a_41684_160275# a_41684_148611# a_41684_148611# VSS nfet_06v0 ad=13p pd=50.52u as=13p ps=50.52u w=50u l=0.7u
X1075 FS_P_OUT PAD_P VSS ppolyf_s r_width=2u r_length=3.5u
X1076 FS_N_OUT FS_N_GATE FS_N_WELL FS_N_WELL pfet_03v3 ad=6.16p pd=28.88u as=6.16p ps=28.88u w=14u l=0.28u
X1077 VDD FS_P_GATE FS_P_WELL FS_P_WELL pfet_03v3 ad=6.16p pd=28.88u as=6.16p ps=28.88u w=14u l=0.28u
D25 VSS PAD_N diode_nd2ps_06v0 pj=51.8u area=22.5p
X1078 a_41684_148611# a_41684_148611# a_41684_160275# VSS nfet_06v0 ad=13p pd=50.52u as=13p ps=50.52u w=50u l=0.7u
X1079 HS_P_0 HS_PBIAS VDD VDD pfet_03v3 ad=8.8p pd=40.88u as=8.8p ps=40.88u w=20u l=1u
X1080 a_41684_160275# a_41684_160275# VSS VSS nfet_06v0 ad=13p pd=50.52u as=13p ps=50.52u w=50u l=0.7u
X1081 TERM_GATE_N_BLEED_2 VSS VSS ppolyf_u_1k r_width=1u r_length=12.5u
X1082 PULLUP_P_OUT PULLUP_P_GATE PULLUP_P_WELL PULLUP_P_WELL pfet_03v3 ad=8.8p pd=40.88u as=8.8p ps=40.88u w=20u l=0.28u
X1083 VDD FS_P_GATE FS_P_WELL FS_P_WELL pfet_03v3 ad=6.16p pd=28.88u as=6.16p ps=28.88u w=14u l=0.28u
X1084 a_41684_160275# a_41684_148611# a_41684_148611# VSS nfet_06v0 ad=13p pd=50.52u as=13p ps=50.52u w=50u l=0.7u
D26 VSS PAD_P diode_nd2ps_06v0 pj=51.8u area=22.5p
X1085 a_42245_90628# a_44789_117064# ESD_RAIL ESD_RAIL pfet_06v0 ad=1.3p pd=5.52u as=1.3p ps=5.52u w=5u l=0.7u
X1086 TERM_P_R TERM_GATE_P TERM_VCM VSS nfet_03v3 ad=8.8p pd=40.88u as=8.8p ps=40.88u w=20u l=0.28u
X1087 a_41684_160275# a_41684_160275# VSS VSS nfet_06v0 ad=13p pd=50.52u as=13p ps=50.52u w=50u l=0.7u
X1088 a_41684_148611# a_41684_148611# a_41684_160275# VSS nfet_06v0 ad=13p pd=50.52u as=13p ps=50.52u w=50u l=0.7u
X1089 FS_N_OUT FS_N_GATE FS_N_WELL FS_N_WELL pfet_03v3 ad=6.16p pd=28.88u as=6.16p ps=28.88u w=14u l=0.28u
X1090 PULLUP_P_BLEED_5 PULLUP_P_BLEED_6 VSS ppolyf_u_1k r_width=1u r_length=12.5u
X1091 TERM_OR_N_B FS_LOW_N TERM_OR_N_NS VSS nfet_03v3 ad=0.88p pd=4.88u as=0.88p ps=4.88u w=2u l=0.28u
X1092 a_41684_160275# a_41684_148611# a_41684_148611# VSS nfet_06v0 ad=13p pd=50.52u as=13p ps=50.52u w=50u l=0.7u
X1093 HS_P_2 HS_P PAD_P VSS nfet_06v0 ad=8.8p pd=40.88u as=8.8p ps=40.88u w=20u l=0.7u
X1094 VSS a_41684_160275# a_41684_160275# VSS nfet_06v0 ad=13p pd=50.52u as=13p ps=50.52u w=50u l=0.7u
X1095 a_41684_160275# a_41684_160275# VSS VSS nfet_06v0 ad=13p pd=50.52u as=13p ps=50.52u w=50u l=0.7u
X1096 VDD FS_P_GATE FS_P_WELL FS_P_WELL pfet_03v3 ad=6.16p pd=28.88u as=6.16p ps=28.88u w=14u l=0.28u
X1097 VSS a_42245_90628# ESD_RAIL VSS nfet_06v0 ad=13p pd=50.52u as=13p ps=50.52u w=50u l=0.7u
D27 VSS TERM_VCM diode_nd2ps_03v3 pj=2.4u area=0.36p
X1098 VSS a_41684_160275# a_41684_160275# VSS nfet_06v0 ad=13p pd=50.52u as=13p ps=50.52u w=50u l=0.7u
X1099 a_41684_160275# a_41684_160275# VSS VSS nfet_06v0 ad=13p pd=50.52u as=13p ps=50.52u w=50u l=0.7u
X1100 HS_N_7 HS_PBIAS VDD VDD pfet_03v3 ad=8.8p pd=40.88u as=8.8p ps=40.88u w=20u l=1u
X1101 FS_N_OUT FS_N_GATE FS_N_WELL FS_N_WELL pfet_03v3 ad=6.16p pd=28.88u as=6.16p ps=28.88u w=14u l=0.28u
X1102 VDD FS_P_GATE FS_P_WELL FS_P_WELL pfet_03v3 ad=6.16p pd=28.88u as=6.16p ps=28.88u w=14u l=0.28u
X1103 ESD_RAIL a_42245_90628# VSS VSS nfet_06v0 ad=13p pd=50.52u as=13p ps=50.52u w=50u l=0.7u
X1104 a_41684_160275# a_41684_148611# a_41684_148611# VSS nfet_06v0 ad=13p pd=50.52u as=13p ps=50.52u w=50u l=0.7u
X1105 VSS a_41684_160275# a_41684_160275# VSS nfet_06v0 ad=13p pd=50.52u as=13p ps=50.52u w=50u l=0.7u
X1106 ESD_RAIL a_42245_90628# VSS VSS nfet_06v0 ad=13p pd=50.52u as=13p ps=50.52u w=50u l=0.7u
X1107 a_41684_148611# a_41684_148611# a_41684_160275# VSS nfet_06v0 ad=13p pd=50.52u as=13p ps=50.52u w=50u l=0.7u
X1108 a_41684_148611# ESD_RAIL ESD_RAIL VSS nfet_06v0 ad=13p pd=50.52u as=13p ps=50.52u w=50u l=0.7u
X1109 a_41684_160275# a_41684_148611# a_41684_148611# VSS nfet_06v0 ad=13p pd=50.52u as=13p ps=50.52u w=50u l=0.7u
X1110 HS_N_9 HS_PBIAS VDD VDD pfet_03v3 ad=8.8p pd=40.88u as=8.8p ps=40.88u w=20u l=1u
X1111 VSS a_41684_160275# a_41684_160275# VSS nfet_06v0 ad=13p pd=50.52u as=13p ps=50.52u w=50u l=0.7u
X1112 a_41684_160275# a_41684_160275# VSS VSS nfet_06v0 ad=13p pd=50.52u as=13p ps=50.52u w=50u l=0.7u
X1113 ESD_RAIL a_42245_90628# VSS VSS nfet_06v0 ad=13p pd=50.52u as=13p ps=50.52u w=50u l=0.7u
X1114 VSS a_42245_90628# ESD_RAIL VSS nfet_06v0 ad=13p pd=50.52u as=13p ps=50.52u w=50u l=0.7u
X1115 a_41684_148611# a_41684_148611# a_41684_160275# VSS nfet_06v0 ad=13p pd=50.52u as=13p ps=50.52u w=50u l=0.7u
X1116 ESD_RAIL a_42245_90628# VSS VSS nfet_06v0 ad=13p pd=50.52u as=13p ps=50.52u w=50u l=0.7u
X1117 a_42245_90628# a_44789_117064# ESD_RAIL ESD_RAIL pfet_06v0 ad=1.3p pd=5.52u as=1.3p ps=5.52u w=5u l=0.7u
X1118 TERM_OR_P_B TERM_ENABLE VSS VSS nfet_03v3 ad=0.88p pd=4.88u as=0.88p ps=4.88u w=2u l=0.28u
X1119 VSS a_41684_160275# a_41684_160275# VSS nfet_06v0 ad=13p pd=50.52u as=13p ps=50.52u w=50u l=0.7u
X1120 ESD_RAIL ESD_RAIL a_41684_148611# VSS nfet_06v0 ad=13p pd=50.52u as=13p ps=50.52u w=50u l=0.7u
X1121 a_41684_160275# a_41684_160275# VSS VSS nfet_06v0 ad=13p pd=50.52u as=13p ps=50.52u w=50u l=0.7u
X1122 TERM_P_R DIFF_ENABLE TERM_N_R VSS nfet_03v3 ad=8.8p pd=40.88u as=8.8p ps=40.88u w=20u l=0.28u
X1123 ESD_RAIL ESD_RAIL a_41684_148611# VSS nfet_06v0 ad=13p pd=50.52u as=13p ps=50.52u w=50u l=0.7u
X1124 a_41684_160275# a_41684_160275# VSS VSS nfet_06v0 ad=13p pd=50.52u as=13p ps=50.52u w=50u l=0.7u
X1125 TERM_OR_P_NS VCM_LOW_OK VSS VSS nfet_03v3 ad=1.76p pd=8.88u as=1.76p ps=8.88u w=4u l=0.28u
X1126 FS_N_OUT FS_N_GATE FS_N_WELL FS_N_WELL pfet_03v3 ad=6.16p pd=28.88u as=6.16p ps=28.88u w=14u l=0.28u
X1127 a_41684_160275# a_41684_148611# a_41684_148611# VSS nfet_06v0 ad=13p pd=50.52u as=13p ps=50.52u w=50u l=0.7u
X1128 TERM_GATE_P_BLEED_1 TERM_GATE_P_BLEED_2 VSS ppolyf_u_1k r_width=1u r_length=12.5u
X1129 a_41684_148611# a_41684_148611# a_41684_160275# VSS nfet_06v0 ad=13p pd=50.52u as=13p ps=50.52u w=50u l=0.7u
X1130 a_42245_90628# a_44789_117064# ESD_RAIL ESD_RAIL pfet_06v0 ad=1.3p pd=5.52u as=1.3p ps=5.52u w=5u l=0.7u
X1131 HS_N_11 HS_N PAD_N VSS nfet_06v0 ad=8.8p pd=40.88u as=8.8p ps=40.88u w=20u l=0.7u
X1132 a_41684_160275# a_41684_160275# VSS VSS nfet_06v0 ad=13p pd=50.52u as=13p ps=50.52u w=50u l=0.7u
X1133 a_41684_148611# ESD_RAIL ESD_RAIL VSS nfet_06v0 ad=13p pd=50.52u as=13p ps=50.52u w=50u l=0.7u
X1134 ESD_RAIL ESD_RAIL a_41684_148611# VSS nfet_06v0 ad=13p pd=50.52u as=13p ps=50.52u w=50u l=0.7u
X1135 VSS a_41684_160275# a_41684_160275# VSS nfet_06v0 ad=13p pd=50.52u as=13p ps=50.52u w=50u l=0.7u
X1136 HS_N_0 HS_N PAD_N VSS nfet_06v0 ad=8.8p pd=40.88u as=8.8p ps=40.88u w=20u l=0.7u
X1137 ESD_RAIL ESD_RAIL a_41684_148611# VSS nfet_06v0 ad=13p pd=50.52u as=13p ps=50.52u w=50u l=0.7u
X1138 a_41684_148611# ESD_RAIL ESD_RAIL VSS nfet_06v0 ad=13p pd=50.52u as=13p ps=50.52u w=50u l=0.7u
X1139 VDD FS_P_GATE FS_P_WELL FS_P_WELL pfet_03v3 ad=6.16p pd=28.88u as=6.16p ps=28.88u w=14u l=0.28u
X1140 ESD_RAIL a_44789_117064# a_42245_90628# ESD_RAIL pfet_06v0 ad=1.3p pd=5.52u as=1.3p ps=5.52u w=5u l=0.7u
X1141 PAD_N BYPASS_ENABLE RX_N VSS nfet_06v0 ad=8.8p pd=40.88u as=8.8p ps=40.88u w=20u l=0.7u
X1142 PAD_N BYPASS_ENABLE RX_N VSS nfet_06v0 ad=8.8p pd=40.88u as=8.8p ps=40.88u w=20u l=0.7u
X1143 a_41005_132385# a_53878_132105# ESD_RAIL ppolyf_u r_width=0.8u r_length=63.855u
X1144 VSS a_41684_160275# a_41684_160275# VSS nfet_06v0 ad=13p pd=50.52u as=13p ps=50.52u w=50u l=0.7u
X1145 a_41684_160275# a_41684_160275# VSS VSS nfet_06v0 ad=13p pd=50.52u as=13p ps=50.52u w=50u l=0.7u
X1146 a_41684_148611# ESD_RAIL ESD_RAIL VSS nfet_06v0 ad=13p pd=50.52u as=13p ps=50.52u w=50u l=0.7u
X1147 VSS a_41684_160275# a_41684_160275# VSS nfet_06v0 ad=13p pd=50.52u as=13p ps=50.52u w=50u l=0.7u
X1148 PULLUP_N_BLEED_2 PULLUP_N_BLEED_3 VSS ppolyf_u_1k r_width=1u r_length=12.5u
X1149 a_41684_148611# a_41684_148611# a_41684_160275# VSS nfet_06v0 ad=13p pd=50.52u as=13p ps=50.52u w=50u l=0.7u
C0 FS_HIGH_P FS_P_BLEED_2 0.03577f
C1 PULLUP_P_BLEED_6 HS_N_9 0.00148f
C2 TERM_OR_P_B HS_N_4 0.07211f
C3 HS_N_6 PULLUP_N_OUT 0.05599f
C4 FS_LOW_P HS_P_1 0.11262f
C5 FS_P_BLEED_2 FS_P_BLEED_3 0.53961f
C6 HS_P_5 TERM_GATE_P_BLEED_0 0.0244f
C7 DIV_LOW_N HS_N_9 0.06178f
C8 HS_N_5 PULLDOWN_N_R 0.06832f
C9 TERM_OR_N_B FS_LOW_N 2.73977f
C10 FS_HIGH_N FS_N_BLEED_4 0.16623f
C11 PULLUP_P_BLEED_6 PULLUP_P_GATE 1.78667f
C12 FS_N_BLEED_1 PULLUP_N_WELL 0
C13 HS_N_7 HS_N_2 0.02926f
C14 HS_N_8 FS_N_GATE 0.00226f
C15 TERM_VCM HS_P_2 0.09615f
C16 HS_N_2 FS_LOW_N 0.08441f
C17 TERM_OR_N_B TERM_OR_N_NS 1.66751f
C18 HS_N_7 FS_LOW_P 0.0855f
C19 HS_N_11 DIV_LOW_N 0.06178f
C20 HS_N_1 PULLUP_P_GATE 0.08375f
C21 HS_P_6 PAD_P 1.8306f
C22 FS_P_BLEED_2 FS_P_BLEED_0 0
C23 HS_P_9 HS_PBIAS 3.39603f
C24 TERM_VCM FS_N_CONTROL_S 0.07594f
C25 HS_N_7 PULLUP_P_CONTROL_S 0.04808f
C26 HS_N_11 HS_N_1 0.03414f
C27 HS_N_2 TERM_OR_N_NS 0.03425f
C28 TERM_OR_P_NS HS_P_10 0.04329f
C29 PULLUP_P_BLEED_4 HS_N_8 0.0525f
C30 HS_P HS_N_0 0.16427f
C31 HS_N FS_P_OUT 20.4712f
C32 TERM_ENABLE HS_P_2 0.06392f
C33 TERM_VCM DIV_ENABLE 0.20793f
C34 FS_LOW_N FS_LOW_P 93.3684f
C35 HS_N_2 PAD_P 1.25659f
C36 FS_HIGH_P VDD 0.65349f
C37 TERM_ENABLE DIV_ENABLE 0.05768f
C38 TERM_OR_N_NS FS_LOW_P 0.12663f
C39 TERM_OR_P_B PULLDOWN_N_R 0.16954f
C40 TERM_ENABLE FS_N_CONTROL_S 0.12118f
C41 FS_LOW_P FS_N_WELL 1.46004f
C42 HS_N_5 FS_P_WELL 1.97115f
C43 VCM_LOW_OK FS_P_OUT 0.37711f
C44 HS_N_13 PULLDOWN_P 0.04428f
C45 DIFF_ENABLE PULLUP_N_BLEED_5 0
C46 FS_LOW_N PULLUP_N_BLEED_0 0.08389f
C47 VDD TERM_GATE_P_BLEED_2 0.084f
C48 PULLUP_N DIFF_ENABLE 0.26007f
C49 PULLUP_P_BLEED_5 HS_N_10 0.02441f
C50 VDD FS_P_BLEED_0 0.66399f
C51 HS_N_0 PULLUP_N_OUT 0.05062f
C52 HS_P_11 VDD 5.06957f
C53 FS_P_BLEED_2 FS_P_BLEED_6 0.06814f
C54 DIV_ENABLE PULLUP_P_BLEED_3 0.01375f
C55 HS_N_12 FS_P_OUT 0.43801f
C56 PULLUP_P HS_N_9 0.02404f
C57 HS_P_5 HS_N_10 0.03489f
C58 PULLUP_P PULLUP_P_GATE 5.95692f
C59 HS_N_5 PULLUP_P_OUT 0.03489f
C60 HS_N TERM_GATE_N_BLEED_0 0.04828f
C61 HS_N_11 PULLUP_P 0.02473f
C62 DIV_N RX_N 1.36638f
C63 HS_N_5 HS_N_8 0.04101f
C64 FS_P_OUT TERM_N_R 0.38548f
C65 HS_N FS_N_BLEED_1 0.11535f
C66 FS_P_BLEED_4 HS_N_4 0.06178f
C67 HS_P_6 HS_N_1 0.06023f
C68 FS_P_BLEED_6 VDD 0.01345f
C69 HS_P HS_P_10 2.44809f
C70 ESD_RAIL a_41005_131545# 96.5489f
C71 HS_P_5 HS_P_12 0.03887f
C72 TERM_OR_P_B PULLUP_P_OUT 0.19951f
C73 HS_N_4 HS_P_0 0.03432f
C74 PAD_N HS_N_6 1.1595f
C75 PULLUP_P_GATE HS_N_9 0.08704f
C76 HS_P_4 PULLDOWN_P_R 0.07466f
C77 DIV_LOW_N HS_N_2 0.06178f
C78 HS_N_4 PULLUP_P_WELL 0.12026f
C79 HS_P_13 TERM_GATE_P 0.15775f
C80 HS_N_2 HS_N_1 0.00962f
C81 FS_N_CONTROL_S FS_N_OUT 0.01993f
C82 PULLDOWN_N_R PULLUP_P_BLEED_0 0.00171f
C83 HS_N_11 HS_N_9 0.02558f
C84 DIV_ENABLE FS_N_OUT 0.15376f
C85 TERM_OR_P_B HS_N_8 0.07245f
C86 a_41684_160275# a_41684_148611# 1.22075p
C87 DIV_LOW_N FS_LOW_P 0.08856f
C88 HS_N_11 PULLUP_P_GATE 0.08345f
C89 FS_N_BLEED_4 FS_N_BLEED_2 0.00855f
C90 a_41005_132945# a_41005_131545# 0
C91 TERM_GATE_N HS_N_4 0.04808f
C92 HS_N_12 TERM_GATE_N_BLEED_0 0.03489f
C93 HS_N_1 FS_LOW_P 0.21255f
C94 HS_N_1 PULLUP_P_CONTROL_S 0.05002f
C95 HS_N_6 HS_P_13 0.05493f
C96 DIV_N HS_N_3 0.03505f
C97 FS_P_BLEED_4 PULLDOWN_N_R 0.05822f
C98 FS_HIGH_N PULLUP_N_GATE 0.01195f
C99 PULLUP_N_OUT HS_P_10 0.08961f
C100 HS_N_7 FS_P_OUT 0.52477f
C101 HS_P_0 PULLDOWN_N_R 0.03037f
C102 PULLDOWN_P DIFF_ENABLE 0.21707f
C103 TERM_OR_P_B DIV_P 0.0223f
C104 FS_N_BLEED_5 FS_LOW_P 0.12388f
C105 TERM_GATE_P_BLEED_0 HS_P_12 0.03636f
C106 RX_N RX_P 20.1628f
C107 HS_N_4 TERM_P_R 0.05893f
C108 PULLDOWN_N_R PULLUP_P_WELL 0.39593f
C109 HS_N_3 TERM_OR_P_NS 0.00153f
C110 TERM_GATE_N_BLEED_0 TERM_N_R 0.17977f
C111 VDD HS_P_7 4.96081f
C112 DIV_N FS_P_BLEED_1 0.10151f
C113 TERM_GATE_N PULLDOWN_N_R 0.12021f
C114 HS_P_2 HS_PBIAS 3.95109f
C115 FS_P_OUT PAD_P 5.92309f
C116 TERM_OR_N_B PULLUP_P 0.09232f
C117 PAD_N HS_N_0 1.42664f
C118 TERM_VCM FS_HIGH_P 0.13992f
C119 HS_N_2 PULLUP_P 0.02404f
C120 DIV_ENABLE HS_PBIAS 0.05806f
C121 FS_N_CONTROL_S HS_PBIAS 0.09439f
C122 PULLDOWN_P_R TERM_OR_P_NS 0.05654f
C123 TERM_ENABLE FS_HIGH_P 0.01303f
C124 TERM_OR_P_B HS_P_9 0.1442f
C125 PULLDOWN_N_R TERM_P_R 0.14117f
C126 HS_P_6 HS_N_9 0.05493f
C127 PULLUP_P FS_LOW_P 0.10849f
C128 PULLUP_P PULLUP_P_CONTROL_S 6.1629f
C129 HS_N_4 HS_P_3 0.00972f
C130 TERM_VCM TERM_GATE_P_BLEED_2 0.02194f
C131 TERM_VCM HS_P_11 0.13824f
C132 HS_N_13 VDD 7.11098f
C133 HS_N_0 HS_P_13 0.02661f
C134 TERM_VCM FS_P_BLEED_0 0.09235f
C135 TERM_OR_N_B HS_N_9 0
C136 HS_N_7 TERM_GATE_N_BLEED_0 0.03489f
C137 HS_N_2 HS_N_9 0
C138 HS_N_11 HS_P_6 0.05932f
C139 FS_P_BLEED_4 PULLUP_P_OUT 0.00257f
C140 TERM_ENABLE TERM_GATE_P_BLEED_2 0.07306f
C141 TERM_GATE_N_BLEED_0 FS_LOW_N 0.07127f
C142 PULLUP_N_BLEED_2 PULLUP_N_WELL 0.00114f
C143 HS_N_2 PULLUP_P_GATE 0.08296f
C144 TERM_ENABLE HS_P_11 0.07923f
C145 FS_HIGH_P PULLUP_P_BLEED_3 0.166f
C146 TERM_ENABLE FS_P_BLEED_0 0.11038f
C147 TERM_OR_P_S FS_LOW_P 0.36544f
C148 FS_N_BLEED_1 FS_LOW_N 0.00106f
C149 FS_P_BLEED_4 HS_N_8 0.06266f
C150 HS_P_12 HS_N_10 0.07709f
C151 HS_N_11 HS_N_2 0.0256f
C152 HS_N_10 FS_P_GATE 1.04113f
C153 PULLUP_P_CONTROL_S HS_N_9 0.04808f
C154 FS_P_WELL TERM_P_R 1.46056f
C155 FS_LOW_P HS_N_9 0.08576f
C156 PULLUP_P_OUT PULLUP_P_WELL 29.1254f
C157 FS_P_BLEED_5 HS_N_10 0.06178f
C158 FS_N_BLEED_1 FS_N_WELL 0.5326f
C159 PULLUP_P_CONTROL_S PULLUP_P_GATE 1.18123f
C160 HS_P HS_N_3 0.21103f
C161 FS_LOW_P PULLUP_P_GATE 0.15193f
C162 HS_P_0 HS_N_8 0.03523f
C163 FS_N_GATE FS_N_CONTROL_S 0.98908f
C164 DIV_N PULLDOWN_P 0.0465f
C165 PULLDOWN_N_R HS_P_3 0.07217f
C166 HS_N_11 PULLUP_P_CONTROL_S 0.04911f
C167 HS_N_8 PULLUP_P_WELL 0.13083f
C168 HS_N_11 FS_LOW_P 0.08505f
C169 DIV_ENABLE FS_N_GATE 0.004f
C170 TERM_VCM FS_P_BLEED_6 0.01859f
C171 PULLDOWN_N_R PULLUP_N_WELL 0.304f
C172 FS_P_CONTROL_S HS_N_10 0.03236f
C173 HS_N_1 FS_P_OUT 0.44686f
C174 PAD_N HS_P_10 0.42477f
C175 TERM_GATE_P_BLEED_1 TERM_GATE_P 0.37616f
C176 DIV_ENABLE PULLUP_P_BLEED_4 0
C177 TERM_ENABLE FS_P_BLEED_6 0.08457f
C178 HS_P_12 FS_P_GATE 0.00294f
C179 TERM_GATE_N HS_N_8 0.05073f
C180 HS_P PULLDOWN_P_R 0.03048f
C181 HS_P FS_P_BLEED_1 0.03472f
C182 FS_P_BLEED_5 FS_P_GATE 0.31234f
C183 PULLUP_P_OUT TERM_P_R 0.25969f
C184 HS_N_3 PULLUP_N_OUT 0.00232f
C185 FS_HIGH_P FS_N_OUT 0.17276f
C186 PULLDOWN_N_R HS_P_8 0.06544f
C187 HS_N_8 TERM_P_R 0.05914f
C188 PULLUP_N PULLUP_N_OUT 0.03945f
C189 FS_P_BLEED_3 FS_N_OUT 0.08101f
C190 HS_P_10 HS_P_13 0.09466f
C191 FS_P_CONTROL_S FS_P_GATE 1.45056f
C192 HS_N HS_N_4 1.43714f
C193 FS_P_BLEED_1 PULLUP_N_OUT 0.06151f
C194 FS_P_BLEED_0 FS_N_OUT 0.28479f
C195 PULLUP_N_OUT PULLDOWN_P_R 0.10143f
C196 HS_P_6 HS_N_2 0.05876f
C197 TERM_VCM HS_P_7 0.11665f
C198 HS_P_2 HS_N_5 0.03089f
C199 DIV_P TERM_P_R 0.02242f
C200 DIFF_ENABLE VDD 0.45362f
C201 HS_P_3 PULLUP_P_OUT 0.05276f
C202 VCM_LOW_OK HS_N_4 0.05893f
C203 TERM_GATE_N_BLEED_0 HS_N_1 0.03489f
C204 DIV_ENABLE HS_N_5 0.03089f
C205 TERM_ENABLE HS_P_7 0.02404f
C206 HS_P_6 FS_LOW_P 0.04566f
C207 HS_N_8 HS_P_3 0.02404f
C208 FS_HIGH_N PULLUP_N_BLEED_6 0.15562f
C209 HS_N_2 FS_LOW_P 0.08505f
C210 FS_N_BLEED_6 VDD 0.00257f
C211 PULLUP_P_WELL BYPASS_ENABLE 0.00823f
C212 FS_HIGH_P HS_PBIAS 0.07608f
C213 HS_N_2 PULLUP_P_CONTROL_S 0.04855f
C214 FS_P_BLEED_6 FS_N_OUT 0.04877f
C215 PAD_N RX_N 9.47377f
C216 TERM_OR_P_B HS_P_2 0.10307f
C217 HS_N PULLDOWN_N_R 0.12564f
C218 HS_N_12 HS_N_4 0
C219 FS_P_BLEED_3 HS_PBIAS 0.07855f
C220 PULLUP_N_GATE FS_N_BLEED_4 0.00498f
C221 FS_P_OUT HS_N_9 0.43377f
C222 PULLDOWN_P FS_N_BLEED_0 0.07407f
C223 HS_P_4 VDD 4.77123f
C224 TERM_VCM HS_N_13 0.17f
C225 HS_P_9 TERM_P_R 0.11568f
C226 TERM_OR_N_S HS_N_10 0.02545f
C227 PULLUP_P_CONTROL_S FS_LOW_P 0.05888f
C228 TERM_OR_P_B DIV_ENABLE 0
C229 PULLUP_P_OUT HS_P_8 0.00135f
C230 VCM_LOW_OK PULLDOWN_N_R 0.09227f
C231 DIV_N FS_P_BLEED_2 0
C232 HS_P_5 TERM_GATE_P 0.15599f
C233 HS_N_6 PULLUP_P_BLEED_5 0.03334f
C234 HS_P_11 HS_PBIAS 9.38284f
C235 HS_N_8 HS_P_8 0.09066f
C236 HS_N_13 TERM_ENABLE 0.10332f
C237 FS_P_BLEED_0 HS_PBIAS 0.08856f
C238 HS_N_11 FS_P_OUT 0.43976f
C239 HS_N_4 TERM_N_R 0.05893f
C240 PULLDOWN_P PULLUP_N_OUT 0.10073f
C241 FS_LOW_P PULLUP_N_BLEED_0 0.05872f
C242 HS_P_5 HS_N_6 0.1437f
C243 HS_N FS_P_WELL 41.6575f
C244 HS_N_12 PULLDOWN_N_R 0.06832f
C245 PULLDOWN_N HS_PBIAS 0.03743f
C246 TERM_GATE_N_BLEED_0 PULLUP_P 0.05462f
C247 PAD_N HS_N_3 1.66755f
C248 VCM_LOW_OK FS_P_WELL 1.23126f
C249 FS_N_BLEED_1 PULLUP_P 0.04819f
C250 HS_N_4 HS_P_1 0.0586f
C251 FS_HIGH_P FS_N_GATE 0.13639f
C252 HS_P_3 HS_P_9 0.04194f
C253 HS_N_13 PULLUP_P_BLEED_3 0.03489f
C254 a_44789_117064# a_41005_131545# 0.02879f
C255 DIV_N VDD 0.3598f
C256 FS_P_BLEED_6 HS_PBIAS 0.08856f
C257 TERM_GATE_P_BLEED_0 TERM_GATE_P 4.84915f
C258 FS_HIGH_P PULLUP_P_BLEED_4 0.03577f
C259 TERM_N_R PULLDOWN_N_R 0.12913f
C260 HS_N_3 HS_P_13 0.02404f
C261 HS_N PULLUP_P_OUT 0.04828f
C262 TERM_GATE_N_BLEED_0 HS_N_9 0.03489f
C263 HS_N_12 FS_P_WELL 2.00803f
C264 PAD_N PULLDOWN_P_R 0.0844f
C265 HS_N_7 HS_N_4 0.07687f
C266 PULLUP_N_OUT PULLUP_P_BLEED_1 0
C267 VDD TERM_OR_P_NS 0.04366f
C268 HS_N_4 FS_LOW_N 0.08441f
C269 HS_N HS_N_8 2.66346f
C270 HS_N_0 PULLUP_P_BLEED_5 0.02492f
C271 TERM_GATE_P_BLEED_0 HS_N_6 0
C272 HS_N_11 TERM_GATE_N_BLEED_0 0.03489f
C273 TERM_VCM DIV_LOW_P 0.00257f
C274 HS_P_9 HS_P_8 30.3927f
C275 VCM_LOW_OK PULLUP_P_OUT 0.13743f
C276 PULLUP_N_WELL BYPASS_ENABLE 0.01588f
C277 HS_N_4 TERM_OR_N_NS 0.03425f
C278 PULLDOWN_N_R HS_P_1 0.06544f
C279 TERM_GATE_N_BLEED_1 HS_N_10 0.0527f
C280 VCM_LOW_OK HS_N_8 0.05893f
C281 HS_P_6 FS_P_OUT 0.15673f
C282 HS_N_4 PAD_P 0.06517f
C283 HS_P_5 HS_N_0 0.03489f
C284 HS_P FS_N_BLEED_3 0.08856f
C285 TERM_N_R FS_P_WELL 1.63349f
C286 PULLDOWN_P_R HS_P_13 0.02404f
C287 HS_P_2 HS_P_0 0.00431f
C288 FS_N_BLEED_3 FS_N_BLEED_0 0.10559f
C289 TERM_VCM DIFF_ENABLE 0.14773f
C290 HS_N_7 PULLDOWN_N_R 0.06832f
C291 HS_N DIV_P 0.08005f
C292 HS_N_12 PULLUP_P_OUT 0.03489f
C293 HS_N_2 FS_P_OUT 0.43576f
C294 FS_LOW_N PULLDOWN_N_R 0.05849f
C295 HS_N_12 HS_N_8 0.03497f
C296 TERM_ENABLE DIFF_ENABLE 0.17128f
C297 HS_P_7 HS_PBIAS 0.78499f
C298 PULLDOWN_N_R TERM_OR_N_NS 0.04764f
C299 PULLDOWN_N_R FS_N_WELL 2.17394f
C300 DIV_ENABLE PULLUP_P_WELL 0.01343f
C301 VCM_LOW_OK DIV_P 0.00892f
C302 FS_P_OUT FS_LOW_P 0.53029f
C303 HS_N_10 TERM_GATE_P 0.10903f
C304 FS_HIGH_P HS_N_5 0.02404f
C305 HS_N_5 FS_P_BLEED_3 0.03351f
C306 FS_N_BLEED_3 PULLUP_N_OUT 0.10124f
C307 PULLDOWN_N_R PAD_P 1.40429f
C308 DIV_ENABLE TERM_GATE_N 0.02173f
C309 TERM_N_R PULLUP_P_OUT 0.09296f
C310 HS_N HS_P_9 0.12189f
C311 TERM_VCM HS_P_4 0.12461f
C312 HS_N_7 FS_P_WELL 1.98759f
C313 HS_P VDD 1.62825f
C314 HS_P_2 TERM_P_R 0.08491f
C315 HS_N_6 HS_N_10 0
C316 HS_N_13 TERM_GATE_N_BLEED_2 0.02404f
C317 HS_N_8 TERM_N_R 0.05914f
C318 TERM_ENABLE HS_P_4 0.07923f
C319 HS_N_5 HS_P_11 0.03089f
C320 HS_N_5 FS_P_BLEED_0 0.06178f
C321 TERM_P_R FS_N_CONTROL_S 0.11557f
C322 FS_N_BLEED_0 VDD 0.04218f
C323 HS_P_12 TERM_GATE_P 0.16452f
C324 DIV_ENABLE TERM_P_R 0.05603f
C325 VCM_LOW_OK HS_P_9 0.0458f
C326 HS_N_13 HS_PBIAS 7.29451f
C327 HS_N BYPASS_ENABLE 0.01049f
C328 TERM_OR_N_B TERM_GATE_N_BLEED_0 0.00163f
C329 HS_N_8 HS_P_1 0.02866f
C330 HS_P_5 HS_P_10 0.0481f
C331 DIV_LOW_N HS_N_4 0.06178f
C332 DIV_LOW_P FS_N_OUT 0.05525f
C333 HS_N_2 TERM_GATE_N_BLEED_0 0.03489f
C334 HS_P_12 HS_N_6 0.06578f
C335 TERM_OR_P_B TERM_GATE_P_BLEED_2 0.00349f
C336 HS_N_6 FS_P_GATE 1.04254f
C337 HS_N_4 HS_N_1 0
C338 PULLUP_N_OUT VDD 5.43573f
C339 HS_N_7 PULLUP_P_OUT 0.03489f
C340 TERM_OR_P_B HS_P_11 0.11938f
C341 TERM_GATE_N_BLEED_0 FS_LOW_P 0.06271f
C342 FS_P_BLEED_5 HS_N_6 0.06178f
C343 HS_N_7 HS_N_8 0.11965p
C344 FS_P_BLEED_6 HS_N_5 0.06178f
C345 HS_P_2 HS_P_3 34.3283f
C346 TERM_VCM DIV_N 0.67599f
C347 FS_N_BLEED_1 FS_LOW_P 0.23767f
C348 FS_LOW_N HS_N_8 0.1267f
C349 HS_N_6 FS_P_CONTROL_S 0.03226f
C350 DIV_N TERM_ENABLE 0.00368f
C351 PULLUP_P_BLEED_6 PULLDOWN_N_R 0.05779f
C352 HS_N_8 TERM_OR_N_NS 0.03425f
C353 HS_N_0 HS_N_10 2.19255f
C354 PULLUP_P_OUT PAD_P 0.43807f
C355 DIV_ENABLE PULLUP_N_WELL 0.06147f
C356 TERM_VCM TERM_OR_P_NS 0.00155f
C357 DIV_LOW_N PULLDOWN_N_R 0.08856f
C358 HS_N_13 FS_N_GATE 0.19342f
C359 TERM_GATE_P_BLEED_0 HS_P_10 0.03777f
C360 HS_N_1 PULLDOWN_N_R 0.02404f
C361 HS_N_8 PAD_P 0.43522f
C362 HS_P_2 HS_P_8 0.03103f
C363 TERM_ENABLE TERM_OR_P_NS 0.1642f
C364 TERM_GATE_P_BLEED_1 PULLDOWN_P_R 0.01413f
C365 HS_N_13 PULLUP_P_BLEED_4 0.0525f
C366 HS_P_9 HS_P_1 0.03494f
C367 DIV_N PULLUP_P_BLEED_3 0.10151f
C368 PULLUP_P_BLEED_2 PULLUP_P_BLEED_1 2.37421f
C369 a_41005_131545# a_41005_131825# 0.03725f
C370 DIV_LOW_P HS_PBIAS 0
C371 HS_N_4 PULLUP_P 0.02473f
C372 HS_P_12 HS_N_0 0.07547f
C373 HS_N_0 FS_P_GATE 1.02982f
C374 HS_N_1 FS_P_WELL 2.10428f
C375 HS_N_0 FS_P_BLEED_5 0.06178f
C376 DIV_P PAD_P 2.52939f
C377 DIFF_ENABLE HS_PBIAS 0.27859f
C378 FS_P_BLEED_4 FS_P_BLEED_3 2.07149f
C379 HS_N_4 HS_N_9 0.04068f
C380 HS_N_0 FS_P_CONTROL_S 0.03296f
C381 FS_HIGH_P PULLUP_P_WELL 0.27585f
C382 PULLDOWN_N_R PULLUP_P 0.04377f
C383 FS_P_BLEED_3 PULLUP_P_WELL 0
C384 HS_N_3 PULLUP_P_BLEED_5 0.02807f
C385 TERM_OR_P_B HS_P_7 0.10117f
C386 HS_N_4 PULLUP_P_GATE 0.08296f
C387 HS_N_11 HS_N_4 0
C388 DIV_N FS_N_OUT 0.07775f
C389 HS_P_9 PAD_P 1.35439f
C390 HS_P_10 HS_N_10 0.09288f
C391 FS_HIGH_P TERM_GATE_N 0.00415f
C392 FS_N_BLEED_6 HS_PBIAS 0.09349f
C393 PULLUP_P_BLEED_6 HS_N_8 0.00108f
C394 HS_N HS_P_2 0.46352f
C395 TERM_VCM HS_P 0.21204f
C396 HS_N_13 HS_N_5 0.10387f
C397 HS_P_0 HS_P_11 0.06445f
C398 HS_N_1 PULLUP_P_OUT 0.03489f
C399 DIV_LOW_N HS_N_8 0.06178f
C400 HS_P_4 HS_PBIAS 8.54683f
C401 BYPASS_ENABLE FS_N_WELL 0.05619f
C402 PAD_N VDD 0.00457f
C403 HS_P_5 HS_N_3 0.03489f
C404 TERM_OR_N_S HS_N_6 0.02755f
C405 HS_N FS_N_CONTROL_S 0.12118f
C406 PULLUP_P_WELL FS_P_BLEED_0 0
C407 HS_N DIV_ENABLE 0.05802f
C408 TERM_ENABLE HS_P 0.05441f
C409 VCM_LOW_OK HS_P_2 0.03489f
C410 BYPASS_ENABLE PAD_P 8.2284f
C411 PULLDOWN_N_R HS_N_9 0.02404f
C412 PULLUP_N_GATE PULLUP_N_BLEED_6 6.07282f
C413 PULLDOWN_P_R PULLUP_P_BLEED_5 0.09218f
C414 DIV_ENABLE VCM_LOW_OK 0
C415 PULLDOWN_N_R PULLUP_P_GATE 0.23555f
C416 HS_P_12 HS_P_10 0.07589f
C417 FS_P_BLEED_4 FS_P_BLEED_6 0.12309f
C418 VDD HS_P_13 6.64318f
C419 HS_N_13 TERM_OR_P_B 0.07271f
C420 HS_N_11 PULLDOWN_N_R 0.06159f
C421 TERM_VCM PULLUP_N_OUT 0.50835f
C422 PULLDOWN_P FS_HIGH_N 0.03743f
C423 TERM_GATE_P_BLEED_2 TERM_P_R 0.06551f
C424 HS_P PULLUP_P_BLEED_3 0.03489f
C425 HS_P_5 PULLDOWN_P_R 0.02404f
C426 FS_P_BLEED_0 TERM_P_R 0.11348f
C427 HS_P_11 TERM_P_R 0.14852f
C428 TERM_ENABLE PULLUP_N_OUT 0.19202f
C429 FS_P_BLEED_6 PULLUP_P_WELL 0.01133f
C430 DIV_ENABLE HS_N_12 0.03143f
C431 FS_N_GATE FS_N_BLEED_6 2.79368f
C432 FS_P_WELL HS_N_9 2.02035f
C433 PULLUP_P_BLEED_2 VDD 0.57693f
C434 RX_P FS_N_OUT 0.01284f
C435 DIV_N HS_PBIAS 0.14108f
C436 PULLDOWN_N TERM_P_R 0.05332f
C437 PULLUP_P PULLUP_P_OUT 0.00257f
C438 ESD_RAIL a_42245_90628# 0.24367p
C439 HS_P_6 HS_N_4 0.0599f
C440 FS_HIGH_P PULLUP_N_WELL 0.30751f
C441 HS_N_11 FS_P_WELL 2.03147f
C442 HS_N_8 PULLUP_P 0.02404f
C443 PULLUP_P_BLEED_3 PULLUP_N_OUT 0.05476f
C444 TERM_N_R FS_N_CONTROL_S 0.12536f
C445 TERM_OR_N_S HS_N_0 0.02686f
C446 DIV_ENABLE TERM_N_R 0.09755f
C447 TERM_GATE_P_BLEED_0 PULLDOWN_P_R 0.12409f
C448 FS_P_BLEED_6 TERM_P_R 0.04565f
C449 HS_P_11 HS_P_3 0.02877f
C450 PULLDOWN_P PULLUP_P_BLEED_5 0
C451 HS_P FS_N_OUT 0.77167f
C452 HS_N_2 HS_N_4 0.00206f
C453 TERM_OR_P_S PULLUP_P_OUT 0.00441f
C454 HS_P_2 HS_P_1 0.0568f
C455 PULLUP_P_OUT HS_N_9 0.03516f
C456 DIV_LOW_N BYPASS_ENABLE 0.00106f
C457 TERM_GATE_N_BLEED_1 HS_N_6 0.0525f
C458 HS_N_4 FS_LOW_P 0.08505f
C459 PULLUP_P_OUT PULLUP_P_GATE 19.8171f
C460 HS_P_0 HS_P_7 0.00469f
C461 HS_N_8 HS_N_9 0.11968p
C462 HS_N_4 PULLUP_P_CONTROL_S 0.04808f
C463 HS_N_11 PULLUP_P_OUT 0.03489f
C464 HS_P_6 PULLDOWN_N_R 0.02414f
C465 HS_N_8 PULLUP_P_GATE 0.08595f
C466 HS_N_11 HS_N_8 0.03489f
C467 TERM_OR_N_B PULLDOWN_N_R 0.04207f
C468 HS_N_3 HS_N_10 0.03951f
C469 HS_P_11 HS_P_8 0.00792f
C470 PULLUP_N_OUT FS_N_OUT 0.50078f
C471 HS_N_2 PULLDOWN_N_R 0.02404f
C472 HS_N_7 DIV_ENABLE 0.03089f
C473 HS_N_6 TERM_GATE_P 0.11785f
C474 DIV_N PULLUP_P_BLEED_4 0
C475 HS_N_13 FS_P_BLEED_4 0.06178f
C476 PULLUP_N_BLEED_2 PULLUP_N_BLEED_0 0.00326f
C477 DIV_ENABLE FS_LOW_N 0.03554f
C478 HS_P_4 HS_N_5 0.13307f
C479 FS_N_WELL FS_N_CONTROL_S 0.9381f
C480 PULLDOWN_N_R FS_LOW_P 0.0629f
C481 FS_N_BLEED_3 FS_HIGH_N 0
C482 HS_P_2 PAD_P 1.20139f
C483 DIV_ENABLE FS_N_WELL 0.23482f
C484 HS_P_7 TERM_P_R 0.08343f
C485 PULLDOWN_N_R PULLUP_P_CONTROL_S 0.08753f
C486 HS_P TERM_GATE_N_BLEED_2 0.10446f
C487 TERM_VCM PAD_N 0.001f
C488 HS_N_13 PULLUP_P_WELL 0.12105f
C489 DIV_ENABLE PAD_P 0.14682f
C490 FS_P_BLEED_1 HS_N_10 0.03472f
C491 PULLDOWN_P FS_N_BLEED_2 0.08856f
C492 PULLDOWN_P_R HS_N_10 0.02436f
C493 HS_P HS_PBIAS 0.16546p
C494 HS_N FS_HIGH_P 0.02498f
C495 HS_P_12 HS_N_3 0.03489f
C496 HS_N_3 FS_P_GATE 1.03504f
C497 HS_N_13 TERM_GATE_N 0.04808f
C498 HS_N_2 FS_P_WELL 1.96621f
C499 TERM_GATE_P_BLEED_1 VDD 0.07121f
C500 PULLDOWN_N_R PULLUP_N_BLEED_0 0.07928f
C501 FS_N_BLEED_0 HS_PBIAS 0.10276f
C502 HS_N_3 FS_P_BLEED_5 0.06178f
C503 HS_N FS_P_BLEED_3 0.0463f
C504 HS_N_0 TERM_GATE_N_BLEED_1 0.05293f
C505 HS_P_9 HS_N_9 0.06704f
C506 TERM_OR_P_B HS_P_4 0.10189f
C507 TERM_VCM HS_P_13 0.09664f
C508 PULLUP_N_OUT TERM_GATE_N_BLEED_2 0.09196f
C509 FS_HIGH_P VCM_LOW_OK 0.02051f
C510 FS_P_WELL FS_LOW_P 1.90293f
C511 HS_N_13 TERM_P_R 0.0965f
C512 HS_N_3 FS_P_CONTROL_S 0.03226f
C513 HS_N HS_P_11 0.6688f
C514 HS_P_12 PULLDOWN_P_R 0.02404f
C515 FS_HIGH_N VDD 0.2016f
C516 PULLDOWN_P_R FS_P_GATE 1.57717f
C517 HS_N FS_P_BLEED_0 0.07763f
C518 HS_P_3 HS_P_7 0.06116f
C519 FS_P_BLEED_1 FS_P_GATE 0.17756f
C520 PULLUP_N_OUT HS_PBIAS 0.76895f
C521 TERM_ENABLE HS_P_13 0.02404f
C522 DIV_N HS_N_5 0.03462f
C523 FS_P_BLEED_5 PULLDOWN_P_R 0.11255f
C524 HS_P_6 HS_N_8 0.04808f
C525 TERM_VCM PULLUP_P_BLEED_2 0.08967f
C526 HS_N_2 PULLUP_P_OUT 0.03489f
C527 HS_N_0 TERM_GATE_P 0.11083f
C528 VCM_LOW_OK TERM_GATE_P_BLEED_2 0.01429f
C529 HS_N PULLDOWN_N 0.05791f
C530 FS_HIGH_P HS_N_12 0.02428f
C531 TERM_OR_N_B HS_N_8 0
C532 VCM_LOW_OK HS_P_11 0.06673f
C533 VCM_LOW_OK FS_P_BLEED_0 0.15599f
C534 HS_N_12 FS_P_BLEED_3 0.02888f
C535 HS_P PULLUP_N_BLEED_1 0.11785f
C536 TERM_ENABLE PULLUP_P_BLEED_2 0.11229f
C537 HS_N_2 HS_N_8 0.00333f
C538 HS_P FS_N_GATE 1.48197f
C539 HS_N_5 TERM_OR_P_NS 0.00258f
C540 PULLUP_P_OUT FS_LOW_P 0.17673f
C541 HS_N_0 HS_N_6 0.04157f
C542 FS_P_BLEED_1 FS_P_CONTROL_S 0
C543 FS_N_BLEED_0 FS_N_GATE 0.40602f
C544 HS_N_1 HS_P_2 0.00649f
C545 DIV_N TERM_OR_P_B 0.00135f
C546 HS_P_8 HS_P_7 30.9838f
C547 HS_N_4 FS_P_OUT 0.43331f
C548 HS_N FS_P_BLEED_6 0.08043f
C549 HS_N_8 PULLUP_P_CONTROL_S 0.04808f
C550 HS_N_8 FS_LOW_P 0.21311f
C551 HS_N_12 HS_P_11 0.11035f
C552 HS_P PULLUP_P_BLEED_4 0.0525f
C553 HS_P_6 DIV_P 0.03388f
C554 HS_N_12 FS_P_BLEED_0 0.06178f
C555 FS_HIGH_P TERM_N_R 0.01124f
C556 DIV_ENABLE DIV_LOW_N 9.85993f
C557 HS_N_13 HS_P_3 0.02464f
C558 PULLDOWN_P FS_N_BLEED_4 0.04811f
C559 DIV_ENABLE HS_N_1 0.03212f
C560 PAD_N FS_N_OUT 4.09186f
C561 PULLUP_P_BLEED_3 PULLUP_P_BLEED_2 3.88784f
C562 TERM_OR_P_B TERM_OR_P_NS 3.40561f
C563 PULLUP_N_OUT PULLUP_N_BLEED_1 0
C564 VCM_LOW_OK FS_P_BLEED_6 0.01451f
C565 FS_N_GATE PULLUP_N_OUT 1.02928f
C566 a_41005_133505# m2_42279_124800# 0
C567 TERM_N_R TERM_GATE_P_BLEED_2 0.8432f
C568 TERM_N_R HS_P_11 0.05722f
C569 DIV_P FS_LOW_P 2.36145f
C570 DIV_ENABLE FS_N_BLEED_5 0
C571 FS_P_OUT PULLDOWN_N_R 0.68986f
C572 HS_P_6 HS_P_9 0.00106f
C573 FS_N_BLEED_3 FS_N_BLEED_2 7.86857f
C574 PULLUP_P_BLEED_4 PULLUP_N_OUT 0.09196f
C575 TERM_N_R FS_P_BLEED_0 0.11444f
C576 HS_P_5 VDD 4.75167f
C577 PULLUP_N_GATE PULLUP_N_BLEED_5 0.24191f
C578 DIV_LOW_P TERM_P_R 0.00106f
C579 HS_N_12 FS_P_BLEED_6 0.06178f
C580 TERM_N_R PULLDOWN_N 0.05478f
C581 PULLUP_N PULLUP_N_GATE 1.36429f
C582 HS_P_10 TERM_GATE_P 0.17903f
C583 HS_N_7 FS_HIGH_P 0.02404f
C584 HS_P_11 HS_P_1 0.05935f
C585 FS_HIGH_P FS_LOW_N 93.2199f
C586 TERM_OR_N_S HS_N_3 0.02557f
C587 HS_P_4 HS_P_0 0.00219f
C588 HS_N_7 FS_P_BLEED_3 0.03794f
C589 HS_P HS_N_5 0.87187f
C590 HS_N HS_P_7 0.15132f
C591 TERM_GATE_N_BLEED_0 HS_N_4 0.03489f
C592 FS_HIGH_P TERM_OR_N_NS 0.00369f
C593 HS_P_9 FS_LOW_P 0.05657f
C594 FS_HIGH_P FS_N_WELL 1.71197f
C595 DIFF_ENABLE TERM_P_R 4.25629f
C596 PULLUP_P FS_N_CONTROL_S 0.10706f
C597 HS_N_6 HS_P_10 0.03097f
C598 FS_P_OUT FS_P_WELL 0.18171p
C599 FS_P_BLEED_6 TERM_N_R 0.05729f
C600 DIV_ENABLE PULLUP_P 0.05123f
C601 HS_N_7 FS_P_BLEED_0 0.06178f
C602 HS_N_7 HS_P_11 0
C603 VCM_LOW_OK HS_P_7 0.03489f
C604 FS_N_BLEED_2 VDD 0.01834f
C605 HS_P_2 HS_N_9 0.03089f
C606 TERM_GATE_P_BLEED_0 VDD 0.12131f
C607 TERM_ENABLE TERM_GATE_P_BLEED_1 0.10319f
C608 PULLUP_P_CONTROL_S BYPASS_ENABLE 0.00444f
C609 TERM_OR_P_B HS_P 0.0917f
C610 HS_N_5 PULLUP_N_OUT 0.04773f
C611 TERM_GATE_N_BLEED_0 PULLDOWN_N_R 0.04828f
C612 a_53878_132665# a_53878_133225# 0.0346f
C613 HS_P_4 TERM_P_R 0.1254f
C614 DIV_ENABLE HS_N_9 0.03089f
C615 HS_P_11 PAD_P 1.25724f
C616 HS_N_13 HS_N 0.98202f
C617 TERM_VCM FS_HIGH_N 0.07041f
C618 FS_N_BLEED_1 PULLDOWN_N_R 0.09111f
C619 HS_P_13 HS_PBIAS 2.35188f
C620 DIV_ENABLE PULLUP_P_GATE 0
C621 FS_P_OUT PULLUP_P_OUT 0.56159f
C622 FS_N_BLEED_3 FS_N_BLEED_4 9.3821f
C623 FS_P_BLEED_2 HS_N_10 0
C624 DIV_N PULLUP_P_WELL 0.08038f
C625 HS_N_13 VCM_LOW_OK 0.05893f
C626 TERM_ENABLE FS_HIGH_N 0.05082f
C627 HS_N_7 FS_P_BLEED_6 0.06178f
C628 HS_N_11 DIV_ENABLE 0.03161f
C629 FS_P_OUT HS_N_8 0.43367f
C630 TERM_OR_P_B PULLUP_N_OUT 0.20772f
C631 HS_P_0 TERM_OR_P_NS 0.07621f
C632 DIV_N TERM_GATE_N 0.02552f
C633 a_44789_117064# a_42245_90628# 10.1844f
C634 PULLDOWN_P PULLUP_N_GATE 0.18497f
C635 HS_N_13 HS_N_12 0.1359p
C636 FS_N_BLEED_6 PULLUP_N_WELL 0
C637 HS_P_4 HS_P_3 33.6448f
C638 HS_N_3 TERM_GATE_N_BLEED_1 0.0525f
C639 FS_P_BLEED_2 FS_P_GATE 0.11441f
C640 FS_P_OUT DIV_P 0.01279f
C641 DIV_N TERM_P_R 0
C642 TERM_OR_N_S PULLDOWN_P 0.10193f
C643 FS_HIGH_P DIV_LOW_N 0.16534f
C644 HS_P_7 HS_P_1 0.05962f
C645 FS_P_BLEED_2 FS_P_BLEED_5 0.12885f
C646 VDD HS_N_10 6.378f
C647 FS_HIGH_P HS_N_1 0.03577f
C648 FS_N_BLEED_4 VDD 0.45117f
C649 HS_N_1 FS_P_BLEED_3 0.02938f
C650 TERM_OR_P_NS TERM_P_R 0.22589f
C651 HS_P_0 RX_P 0
C652 HS_N_13 TERM_N_R 0.10989f
C653 HS_N_7 HS_P_7 0
C654 HS_P_6 HS_P_2 0.06956f
C655 FS_HIGH_P FS_N_BLEED_5 0.01355f
C656 HS_P_4 HS_P_8 0.0312f
C657 HS_N_3 TERM_GATE_P 0.11104f
C658 TERM_ENABLE PULLUP_P_BLEED_5 0
C659 TERM_GATE_N_BLEED_0 HS_N_8 0.03489f
C660 HS_N DIV_LOW_P 0.06611f
C661 TERM_VCM HS_P_5 0.09615f
C662 HS_N_1 HS_P_11 0.02846f
C663 HS_N_1 FS_P_BLEED_0 0.06178f
C664 HS_P_12 VDD 4.78775f
C665 VDD FS_P_GATE 26.6621f
C666 HS_N_3 HS_N_6 0.04183f
C667 HS_P FS_P_BLEED_4 0.06337f
C668 TERM_ENABLE HS_P_5 0.02404f
C669 PULLUP_P_BLEED_4 PULLUP_P_BLEED_2 0
C670 HS_N_2 HS_P_2 0.06704f
C671 FS_HIGH_N FS_N_OUT 0.03054f
C672 HS_P_7 PAD_P 1.52213f
C673 HS_P HS_P_0 17.7665f
C674 PULLUP_P_BLEED_3 PULLUP_P_BLEED_5 0.00153f
C675 HS_N DIFF_ENABLE 0.3376f
C676 PULLDOWN_P_R TERM_GATE_P 0.30143f
C677 PULLUP_N_OUT PULLUP_P_BLEED_0 0.04637f
C678 HS_P PULLUP_P_WELL 0.18882f
C679 DIV_ENABLE HS_N_2 0.03089f
C680 PAD_N HS_N_5 1.1645f
C681 HS_P_2 FS_LOW_P 0.04618f
C682 HS_P_3 TERM_OR_P_NS 0.02846f
C683 HS_N_0 RX_N 0.00305f
C684 HS_N_13 HS_N_7 0.09546f
C685 FS_P_CONTROL_S VDD 0.38621f
C686 FS_HIGH_P PULLUP_P 0.06616f
C687 ESD_RAIL a_53878_133225# 0.53916f
C688 FS_LOW_P FS_N_CONTROL_S 0.04634f
C689 PULLUP_N_BLEED_5 PULLUP_N_BLEED_6 4.58267f
C690 HS_P TERM_GATE_N 0.05324f
C691 DIV_ENABLE FS_LOW_P 0.10881f
C692 HS_N_13 FS_LOW_N 0.08441f
C693 DIV_ENABLE PULLUP_P_CONTROL_S 0.00795f
C694 TERM_VCM FS_N_BLEED_2 0.02041f
C695 HS_N_12 DIV_LOW_P 0.00136f
C696 HS_N_6 PULLDOWN_P_R 0.02404f
C697 FS_P_BLEED_1 HS_N_6 0.03472f
C698 HS_N_1 FS_P_BLEED_6 0.06178f
C699 FS_P_BLEED_4 PULLUP_N_OUT 0
C700 PULLUP_N PULLUP_N_BLEED_6 0.17333f
C701 HS_N_13 TERM_OR_N_NS 0.03425f
C702 HS_N FS_N_BLEED_6 0.07097f
C703 HS_N_13 FS_N_WELL 0.00988f
C704 HS_N HS_P_4 0.15877f
C705 HS_P_0 PULLUP_N_OUT 0.09237f
C706 HS_N_5 HS_P_13 0.05493f
C707 TERM_ENABLE TERM_GATE_P_BLEED_0 0.09803f
C708 TERM_ENABLE FS_N_BLEED_2 0.08954f
C709 PULLDOWN_P TERM_GATE_N_BLEED_1 0.07928f
C710 PULLUP_N_OUT PULLUP_P_WELL 0.6012f
C711 FS_N_BLEED_3 PULLUP_N_GATE 0
C712 HS_N_13 PAD_P 0.08152f
C713 DIV_ENABLE PULLUP_N_BLEED_0 0
C714 HS_P TERM_P_R 0.07234f
C715 HS_P_8 TERM_OR_P_NS 0.02846f
C716 FS_HIGH_P HS_N_9 0.02404f
C717 FS_P_BLEED_3 HS_N_9 0.04642f
C718 HS_P_4 VCM_LOW_OK 0.06673f
C719 HS_N_0 HS_N_3 0.08089f
C720 TERM_GATE_N PULLUP_N_OUT 0.23412f
C721 FS_HIGH_P PULLUP_P_GATE 0.03189f
C722 FS_HIGH_N HS_PBIAS 0.03743f
C723 FS_P_BLEED_3 PULLUP_P_GATE 0
C724 HS_N_11 FS_HIGH_P 0.02435f
C725 TERM_OR_P_B HS_P_13 0.10389f
C726 HS_N_11 FS_P_BLEED_3 0.029f
C727 TERM_GATE_N_BLEED_0 BYPASS_ENABLE 0.00766f
C728 HS_P_5 FS_N_OUT 0.06167f
C729 TERM_N_R DIFF_ENABLE 6.47766f
C730 HS_P_11 HS_N_9 0.03103f
C731 PULLUP_N_OUT TERM_P_R 0.26239f
C732 HS_N_9 FS_P_BLEED_0 0.06178f
C733 HS_P HS_P_3 1.89056f
C734 HS_N_11 HS_P_11 0.06806f
C735 DIV_N HS_N 0.0509f
C736 HS_N_0 PULLDOWN_P_R 0.02508f
C737 FS_P_BLEED_1 HS_N_0 0.03472f
C738 TERM_VCM HS_N_10 0.12019f
C739 HS_N_11 FS_P_BLEED_0 0.06178f
C740 PULLDOWN_P HS_N_6 0.04428f
C741 PULLUP_N_GATE VDD 11.92f
C742 HS_P PULLUP_N_WELL 0.25435f
C743 HS_N_4 PULLDOWN_N_R 0.06159f
C744 TERM_VCM FS_N_BLEED_4 0.04263f
C745 TERM_ENABLE HS_N_10 0.04862f
C746 a_41005_132385# m2_42279_124800# 0
C747 HS_P_4 TERM_N_R 0.05722f
C748 TERM_OR_N_S VDD 10.1707f
C749 FS_N_BLEED_0 PULLUP_N_WELL 0
C750 DIV_N VCM_LOW_OK 0.00178f
C751 PULLUP_N_BLEED_2 PULLDOWN_N_R 0.05146f
C752 TERM_ENABLE FS_N_BLEED_4 0.06151f
C753 FS_P_BLEED_6 HS_N_9 0.06178f
C754 FS_HIGH_N FS_N_GATE 8.87893f
C755 PULLUP_P_BLEED_5 HS_PBIAS 0.17636f
C756 HS_N_13 DIV_LOW_N 0.06178f
C757 PULLDOWN_P PULLUP_N_BLEED_6 0.04122f
C758 PULLUP_N_OUT HS_P_3 0.08633f
C759 HS_P HS_P_8 3.0077f
C760 HS_N_13 HS_N_1 0.04843f
C761 FS_P_BLEED_6 PULLUP_P_GATE 0.023f
C762 TERM_VCM FS_P_GATE 0.64724f
C763 VCM_LOW_OK TERM_OR_P_NS 2.92628f
C764 FS_LOW_N DIFF_ENABLE 0.20718f
C765 TERM_VCM HS_P_12 0.107f
C766 DIV_N HS_N_12 0.03462f
C767 HS_P_4 HS_P_1 0.03207f
C768 HS_N_11 FS_P_BLEED_6 0.06178f
C769 PULLUP_N_OUT PULLUP_N_WELL 30.7254f
C770 HS_N_4 FS_P_WELL 1.9794f
C771 PULLUP_P_BLEED_3 HS_N_10 0.03489f
C772 HS_P_5 HS_PBIAS 3.80328f
C773 TERM_ENABLE HS_P_12 0.02404f
C774 TERM_ENABLE FS_P_GATE 1.00704f
C775 DIV_ENABLE FS_P_OUT 0.0629f
C776 TERM_ENABLE FS_P_BLEED_5 0.00492f
C777 PAD_N HS_P_0 0.38312f
C778 FS_LOW_N FS_N_BLEED_6 0
C779 FS_HIGH_P HS_N_2 0.02404f
C780 HS_N_0 PULLDOWN_P 0.04428f
C781 PULLUP_N_OUT HS_P_8 0.0429f
C782 DIV_N TERM_N_R 0.14748f
C783 HS_P_6 HS_P_11 0.06713f
C784 HS_N_2 FS_P_BLEED_3 0.02846f
C785 PULLDOWN_P_R HS_P_10 0.07466f
C786 FS_HIGH_P FS_LOW_P 8.96385f
C787 FS_HIGH_P PULLUP_P_CONTROL_S 0.12623f
C788 HS_N_4 PULLUP_P_OUT 0.03489f
C789 PULLUP_P_BLEED_2 PULLUP_P_BLEED_0 0.10891f
C790 HS_P_7 HS_N_9 0.0401f
C791 PULLDOWN_N_R FS_P_WELL 2.83843f
C792 HS_P_0 HS_P_13 0.01899f
C793 TERM_N_R TERM_OR_P_NS 0.1011f
C794 HS_P_4 PAD_P 1.13663f
C795 FS_N_BLEED_2 HS_PBIAS 0.08856f
C796 HS_N_2 FS_P_BLEED_0 0.06178f
C797 HS_N_13 PULLUP_P 0.07466f
C798 HS_N_4 HS_N_8 0.04079f
C799 HS_N HS_P 2.27647f
C800 HS_N_2 HS_P_11 0.03089f
C801 PULLUP_P_BLEED_4 PULLUP_P_BLEED_5 4.64605f
C802 FS_HIGH_P PULLUP_N_BLEED_0 0.01347f
C803 HS_P_11 FS_LOW_P 0.05239f
C804 HS_N FS_N_BLEED_0 0.11535f
C805 TERM_OR_P_B TERM_GATE_P_BLEED_1 0.00371f
C806 HS_P VCM_LOW_OK 0.06526f
C807 TERM_OR_P_NS HS_P_1 0.04312f
C808 HS_N_1 DIV_LOW_P 0.00376f
C809 DIV_N HS_N_7 0.03462f
C810 DIV_ENABLE TERM_GATE_N_BLEED_0 0.01375f
C811 PULLUP_P_BLEED_2 PULLUP_P_WELL 0
C812 HS_N_13 HS_N_9 0.08666f
C813 DIV_N FS_LOW_N 0.03551f
C814 PULLDOWN_N_R PULLUP_P_OUT 0.10342f
C815 FS_P_GATE FS_N_OUT 0.35576f
C816 HS_P_13 TERM_P_R 0.08554f
C817 HS_N PULLUP_N_OUT 0.10855f
C818 HS_P_12 FS_N_OUT 0.12335f
C819 DIV_N TERM_OR_N_NS 0
C820 HS_N_8 PULLDOWN_N_R 0.02404f
C821 FS_P_BLEED_5 FS_N_OUT 0.05624f
C822 HS_P HS_N_12 0.78589f
C823 HS_N_7 TERM_OR_P_NS 0.00491f
C824 HS_N_13 PULLUP_P_GATE 0.08296f
C825 HS_N_2 FS_P_BLEED_6 0.06178f
C826 VDD TERM_GATE_P 7.09843f
C827 HS_N_13 HS_N_11 0.09269f
C828 TERM_VCM PULLUP_N_GATE 0.19338f
C829 FS_N_GATE FS_N_BLEED_2 0.19042f
C830 DIV_N PAD_P 0.45367f
C831 VCM_LOW_OK PULLUP_N_OUT 0.20396f
C832 TERM_GATE_N_BLEED_2 HS_N_10 0.02441f
C833 PAD_N HS_P_3 0.257f
C834 PULLUP_P_BLEED_2 TERM_P_R 0.11063f
C835 PULLUP_N_BLEED_3 PULLUP_N_GATE 0.13233f
C836 TERM_ENABLE PULLUP_N_GATE 0.24055f
C837 FS_P_CONTROL_S FS_N_OUT 0.00663f
C838 TERM_VCM TERM_OR_N_S 0
C839 HS_N_6 VDD 6.90044f
C840 HS_N_10 HS_PBIAS 1.13923f
C841 PULLUP_P_OUT FS_P_WELL 3.0456f
C842 HS_N_5 PULLUP_P_BLEED_5 0.03089f
C843 DIV_P PULLDOWN_N_R 0.01299f
C844 HS_P TERM_N_R 0.08926f
C845 HS_N_12 PULLUP_N_OUT 0.04377f
C846 FS_N_BLEED_4 HS_PBIAS 0.04811f
C847 HS_N_8 FS_P_WELL 1.99903f
C848 TERM_ENABLE TERM_OR_N_S 5.34861f
C849 HS_P_6 HS_P_7 31.6746f
C850 HS_P_3 HS_P_13 0.2651f
C851 HS_P_5 HS_N_5 0.10295f
C852 PULLUP_N PULLUP_N_BLEED_5 0.06639f
C853 PAD_N HS_P_8 0.85512f
C854 FS_N_BLEED_5 FS_N_BLEED_6 1.15313f
C855 HS_N_0 FS_P_BLEED_2 0
C856 VDD PULLUP_N_BLEED_6 0.45117f
C857 HS_P HS_P_1 4.17389f
C858 HS_P_12 HS_PBIAS 4.10448f
C859 FS_P_GATE HS_PBIAS 1.80592f
C860 ESD_RAIL PAD_P 24.1165f
C861 FS_P_BLEED_5 HS_PBIAS 0.08856f
C862 PULLDOWN_N_R HS_P_9 4.1634f
C863 DIFF_ENABLE PULLUP_P 0.20063f
C864 TERM_N_R PULLUP_N_OUT 0.30705f
C865 FS_HIGH_P FS_P_OUT 0.13265f
C866 HS_N_3 PULLDOWN_P_R 0.02404f
C867 FS_P_BLEED_1 HS_N_3 0.03472f
C868 FS_LOW_P HS_P_7 0.04566f
C869 RX_P PAD_P 8.57241f
C870 TERM_OR_P_B HS_P_5 0.10156f
C871 HS_N_8 PULLUP_P_OUT 0.0351f
C872 HS_P_8 HS_P_13 0.05624f
C873 HS_N_7 HS_P 0.33704f
C874 HS_N_13 HS_P_6 0.05888f
C875 FS_N_GATE HS_N_10 0.00893f
C876 FS_P_CONTROL_S HS_PBIAS 0.04861f
C877 HS_P FS_LOW_N 0.08532f
C878 HS_N_11 DIV_LOW_P 0.00184f
C879 DIV_N DIV_LOW_N 6.86692f
C880 TERM_GATE_P_BLEED_0 HS_N_5 0
C881 PULLUP_N_OUT HS_P_1 0.05947f
C882 HS_N_0 VDD 4.91768f
C883 FS_LOW_N FS_N_BLEED_0 0.00206f
C884 HS_P TERM_OR_N_NS 0.03425f
C885 DIV_N HS_N_1 0.03462f
C886 FS_N_GATE FS_N_BLEED_4 0.27893f
C887 HS_P FS_N_WELL 2.92153f
C888 PULLUP_P_BLEED_4 HS_N_10 0.0527f
C889 FS_P_BLEED_1 PULLDOWN_P_R 0.05445f
C890 HS_N_13 HS_N_2 0.12568p
C891 FS_N_BLEED_0 FS_N_WELL 2.72415f
C892 HS_P PAD_P 39.8004f
C893 HS_N PAD_N 35.6371f
C894 HS_N_7 PULLUP_N_OUT 0.05812f
C895 HS_N_13 FS_LOW_P 0.08505f
C896 TERM_VCM TERM_GATE_N_BLEED_1 0.00966f
C897 HS_N_13 PULLUP_P_CONTROL_S 0.04867f
C898 PULLUP_N_CONTROL_S PULLUP_N_OUT 0.004f
C899 FS_LOW_N PULLUP_N_OUT 0.06432f
C900 TERM_OR_P_B TERM_GATE_P_BLEED_0 0.0048f
C901 FS_P_WELL BYPASS_ENABLE 0.05062f
C902 TERM_ENABLE TERM_GATE_N_BLEED_1 0.07928f
C903 PULLUP_N_OUT TERM_OR_N_NS 0.05397f
C904 PULLUP_N_OUT FS_N_WELL 2.10234f
C905 TERM_GATE_P_BLEED_1 TERM_P_R 0.00257f
C906 FS_HIGH_P TERM_GATE_N_BLEED_0 0.15807f
C907 HS_P_4 HS_N_9 0.03089f
C908 PULLDOWN_P PULLUP_N_BLEED_5 0
C909 PULLUP_P_OUT HS_P_9 0.06897f
C910 HS_N HS_P_13 0.35374f
C911 FS_HIGH_P FS_N_BLEED_1 0
C912 PULLUP_N_OUT PAD_P 0.11127f
C913 PULLUP_N PULLDOWN_P 5.21685f
C914 TERM_VCM TERM_GATE_P 26.4481f
C915 HS_N_8 HS_P_9 0.00649f
C916 PAD_N HS_N_12 1.21768f
C917 DIV_N PULLUP_P 0.04512f
C918 FS_HIGH_N TERM_P_R 0.05398f
C919 VCM_LOW_OK HS_P_13 0.03489f
C920 TERM_ENABLE TERM_GATE_P 1.60491f
C921 HS_N_5 HS_N_10 0
C922 PULLUP_N_GATE HS_PBIAS 0.14584f
C923 TERM_VCM HS_N_6 0.17751f
C924 VDD HS_P_10 6.63169f
C925 PULLDOWN_P PULLDOWN_P_R 2.2366f
C926 HS_N_4 HS_P_2 0.00376f
C927 HS_P PULLUP_P_BLEED_6 0.00212f
C928 VCM_LOW_OK PULLUP_P_BLEED_2 0.15227f
C929 HS_N_12 HS_P_13 0.02465f
C930 HS_P DIV_LOW_N 0.06178f
C931 PAD_N TERM_N_R 0.56726f
C932 TERM_ENABLE HS_N_6 0.10332f
C933 HS_N_2 DIV_LOW_P 0
C934 HS_P_5 HS_P_0 0.00297f
C935 TERM_OR_N_S HS_PBIAS 0.12657f
C936 DIV_N HS_N_9 0.03462f
C937 HS_P HS_N_1 0.13598f
C938 TERM_OR_P_B HS_N_10 0.0738f
C939 DIV_ENABLE HS_N_4 0.03089f
C940 HS_P_12 HS_N_5 0.06578f
C941 DIV_N PULLUP_P_GATE 0.00178f
C942 TERM_VCM PULLUP_N_BLEED_6 0.04263f
C943 DIV_LOW_P FS_LOW_P 0.12545f
C944 HS_N_5 FS_P_GATE 1.04072f
C945 DIV_N HS_N_11 0.03462f
C946 TERM_OR_P_S TERM_OR_P_NS 0.00736f
C947 HS_N_5 FS_P_BLEED_5 0.06178f
C948 PAD_N HS_P_1 0.56708f
C949 TERM_OR_P_NS HS_N_9 0.01002f
C950 PULLUP_N_BLEED_3 PULLUP_N_BLEED_6 0.0078f
C951 TERM_ENABLE PULLUP_N_BLEED_6 0.06151f
C952 FS_HIGH_N PULLUP_N_WELL 0.30788f
C953 TERM_GATE_N_BLEED_1 FS_N_OUT 0.06408f
C954 DIV_P BYPASS_ENABLE 0.05958f
C955 HS_P_2 PULLDOWN_N_R 0.07217f
C956 PULLUP_P_BLEED_6 PULLUP_N_OUT 0.09268f
C957 PULLUP_P_BLEED_3 HS_N_6 0.03489f
C958 DIV_LOW_N PULLUP_N_OUT 0.10124f
C959 DIFF_ENABLE FS_LOW_P 0.27413f
C960 HS_N_5 FS_P_CONTROL_S 0.03226f
C961 PULLUP_N_GATE PULLUP_N_BLEED_1 0.05777f
C962 TERM_OR_P_B HS_P_12 0.13059f
C963 HS_P_6 HS_P_4 0.06956f
C964 PULLDOWN_N_R FS_N_CONTROL_S 0.09439f
C965 HS_N_7 PAD_N 1.7635f
C966 DIV_ENABLE PULLDOWN_N_R 0.04455f
C967 HS_P_5 TERM_P_R 0.08374f
C968 TERM_VCM HS_N_0 0.17286f
C969 TERM_N_R PULLUP_P_BLEED_2 0.11444f
C970 HS_N_13 FS_P_OUT 0.52823f
C971 TERM_GATE_P_BLEED_0 HS_P_0 0.00591f
C972 HS_P_13 HS_P_1 0.11352f
C973 ESD_RAIL m2_42279_124800# 5.47988f
C974 TERM_GATE_P FS_N_OUT 0.1125f
C975 FS_N_BLEED_6 FS_LOW_P 0.05624f
C976 TERM_ENABLE HS_N_0 0.10582f
C977 HS_P PULLUP_P 0.02404f
C978 HS_P_4 FS_LOW_P 0.04599f
C979 HS_N_7 HS_P_13 0.02404f
C980 PAD_N PAD_P 58.971f
C981 DIV_ENABLE FS_P_WELL 0.08405f
C982 TERM_GATE_N_BLEED_1 TERM_GATE_N_BLEED_2 5.57305f
C983 a_41005_132945# m2_42279_124800# 0
C984 TERM_GATE_N_BLEED_1 HS_PBIAS 0.07928f
C985 FS_N_BLEED_2 TERM_P_R 0.04588f
C986 HS_P_5 HS_P_3 0.03192f
C987 PULLUP_P_BLEED_3 HS_N_0 0.03489f
C988 TERM_GATE_P_BLEED_0 TERM_P_R 0.00257f
C989 DIV_N HS_P_6 0
C990 HS_P HS_N_9 0.12097p
C991 HS_P_13 PAD_P 1.35247f
C992 PULLUP_N_OUT PULLUP_P 29.6142f
C993 PULLUP_N_GATE PULLUP_N_BLEED_4 0.20501f
C994 FS_P_BLEED_1 FS_P_BLEED_2 1.41312f
C995 HS_P PULLUP_P_GATE 0.08871f
C996 HS_P_2 PULLUP_P_OUT 0.06773f
C997 DIV_N HS_N_2 0.03462f
C998 FS_P_BLEED_4 HS_N_10 0.06178f
C999 PULLUP_N_BLEED_5 VDD 0.55431f
C1000 HS_P_6 TERM_OR_P_NS 0.02846f
C1001 HS_N_3 VDD 5.65374f
C1002 HS_N FS_HIGH_N 0.06561f
C1003 HS_N_11 HS_P 0.77257f
C1004 HS_P_2 HS_N_8 0.02404f
C1005 HS_N_13 TERM_GATE_N_BLEED_0 0.03489f
C1006 HS_P_0 HS_N_10 0.06989f
C1007 DIV_N PULLUP_P_CONTROL_S 0.06087f
C1008 TERM_GATE_P HS_PBIAS 0.02241f
C1009 PULLUP_N VDD 0.00338f
C1010 DIV_N FS_LOW_P 6.0078f
C1011 DIV_ENABLE HS_N_8 0.03089f
C1012 PULLUP_P_WELL HS_N_10 0.14098f
C1013 TERM_VCM HS_P_10 0.13491f
C1014 HS_P_5 HS_P_8 0.00106f
C1015 HS_N_6 TERM_GATE_N_BLEED_2 0.03334f
C1016 FS_P_OUT DIV_LOW_P 0.13605f
C1017 PULLUP_N_OUT HS_N_9 0.01492f
C1018 TERM_GATE_P_BLEED_0 HS_P_3 0.02464f
C1019 TERM_OR_N_S HS_N_5 0.02662f
C1020 TERM_ENABLE HS_P_10 0.0768f
C1021 PULLUP_N_OUT PULLUP_P_GATE 0.36087f
C1022 TERM_GATE_N HS_N_10 0.04869f
C1023 HS_N_0 FS_N_OUT 0.06167f
C1024 TERM_OR_P_NS FS_LOW_P 0.39723f
C1025 HS_N_6 HS_PBIAS 7.23511f
C1026 FS_P_BLEED_4 FS_P_GATE 0.27551f
C1027 PULLDOWN_P_R VDD 1.92312f
C1028 FS_P_BLEED_1 VDD 0.44675f
C1029 HS_N_11 PULLUP_N_OUT 0.01419f
C1030 PULLUP_N_WELL FS_N_BLEED_2 0
C1031 FS_P_BLEED_4 FS_P_BLEED_5 3.61839f
C1032 HS_P_12 HS_P_0 0.08899f
C1033 FS_HIGH_P HS_N_4 0.02404f
C1034 PAD_N HS_N_1 1.13339f
C1035 DIV_ENABLE DIV_P 4.76769f
C1036 TERM_GATE_P_BLEED_1 TERM_N_R 0.23767f
C1037 HS_N_10 TERM_P_R 0.06034f
C1038 FS_N_BLEED_3 PULLDOWN_P 0.08856f
C1039 HS_N_4 FS_P_BLEED_3 0.03227f
C1040 PULLUP_P_WELL FS_P_GATE 0
C1041 FS_P_BLEED_5 PULLUP_P_WELL 0.00636f
C1042 HS_N PULLUP_P_BLEED_5 0.05048f
C1043 PULLUP_N_BLEED_6 HS_PBIAS 0.04828f
C1044 TERM_GATE_P_BLEED_0 HS_P_8 0.0271f
C1045 FS_N_BLEED_4 TERM_P_R 0.04766f
C1046 HS_N_4 FS_P_BLEED_0 0.06178f
C1047 HS_P_2 HS_P_9 0.0419f
C1048 HS_N_1 HS_P_13 0.12155f
C1049 HS_N_4 HS_P_11 0.06606f
C1050 FS_HIGH_N TERM_N_R 0.05037f
C1051 HS_P_6 HS_P 3.46603f
C1052 HS_N HS_P_5 0.39228f
C1053 VCM_LOW_OK PULLUP_P_BLEED_5 0
C1054 FS_HIGH_P PULLDOWN_N_R 0.04377f
C1055 HS_P_12 TERM_P_R 0.11066f
C1056 HS_P TERM_OR_N_B 0
C1057 FS_P_GATE TERM_P_R 0.79885f
C1058 HS_N_0 TERM_GATE_N_BLEED_2 0.02492f
C1059 HS_P HS_N_2 0.85293f
C1060 HS_P_5 VCM_LOW_OK 0.03489f
C1061 HS_N_0 HS_PBIAS 7.78201f
C1062 HS_P_3 HS_N_10 0.02545f
C1063 HS_N_12 PULLUP_P_BLEED_5 0.02427f
C1064 PULLUP_P_BLEED_4 HS_N_6 0.0525f
C1065 PULLDOWN_P VDD 1.70977f
C1066 DIV_ENABLE BYPASS_ENABLE 75.0001f
C1067 HS_P_11 PULLDOWN_N_R 0.07466f
C1068 HS_P PULLUP_P_CONTROL_S 0.04808f
C1069 PULLDOWN_N_R FS_P_BLEED_0 0.10124f
C1070 PULLUP_N_BLEED_1 PULLUP_N_BLEED_6 0.00257f
C1071 HS_P FS_LOW_P 0.09863f
C1072 HS_N_4 FS_P_BLEED_6 0.06178f
C1073 HS_N_5 TERM_GATE_N_BLEED_1 0.0525f
C1074 HS_P_6 PULLUP_N_OUT 0.02846f
C1075 FS_N_BLEED_4 PULLUP_N_WELL 0.01353f
C1076 FS_N_BLEED_0 FS_LOW_P 0.79203f
C1077 FS_HIGH_P FS_P_WELL 6.72442f
C1078 HS_P_5 HS_N_12 0.03489f
C1079 PULLDOWN_N PULLDOWN_N_R 2.99559f
C1080 HS_N FS_N_BLEED_2 0.11535f
C1081 TERM_OR_N_B PULLUP_N_OUT 0.09609f
C1082 FS_HIGH_N FS_LOW_N 0.08748f
C1083 HS_P PULLUP_N_BLEED_0 0.07928f
C1084 HS_P_12 HS_P_3 0.02899f
C1085 DIV_N FS_P_OUT 0.05123f
C1086 PAD_N HS_N_9 1.0992f
C1087 FS_HIGH_N FS_N_WELL 2.50709f
C1088 PULLUP_N_OUT PULLUP_P_CONTROL_S 0.08753f
C1089 TERM_VCM PULLUP_N_BLEED_5 0.13759f
C1090 PULLUP_N_OUT FS_LOW_P 0.07132f
C1091 TERM_VCM HS_N_3 0.12325f
C1092 HS_N_5 TERM_GATE_P 0.11502f
C1093 FS_P_WELL FS_P_BLEED_0 6.36796f
C1094 HS_N_11 PAD_N 1.22201f
C1095 FS_P_BLEED_6 PULLDOWN_N_R 0.10124f
C1096 PULLUP_P_BLEED_1 VDD 0.07323f
C1097 PULLUP_N_BLEED_3 PULLUP_N_BLEED_5 0.10602f
C1098 FS_HIGH_P PULLUP_P_OUT 0.10214f
C1099 TERM_ENABLE HS_N_3 0.04808f
C1100 PULLUP_P PULLUP_P_BLEED_2 0.14463f
C1101 TERM_ENABLE PULLUP_N_BLEED_5 0.11535f
C1102 HS_N_9 HS_P_13 0.05493f
C1103 FS_P_BLEED_3 PULLUP_P_OUT 0.00257f
C1104 HS_P_12 HS_P_8 0
C1105 PULLUP_N TERM_ENABLE 0.01513f
C1106 HS_N_5 HS_N_6 0.12181p
C1107 HS_N_0 PULLUP_P_BLEED_4 0.05293f
C1108 FS_HIGH_P HS_N_8 0.03528f
C1109 PULLUP_N PULLUP_N_BLEED_3 0.121f
C1110 ESD_RAIL a_43813_117064# 4.89902f
C1111 a_41005_131545# a_42245_90628# 0.0135f
C1112 HS_N_8 FS_P_BLEED_3 0.04176f
C1113 a_53878_133785# a_53878_133225# 0.0346f
C1114 HS_P_5 HS_P_1 0.02411f
C1115 HS_P_10 HS_PBIAS 8.55407f
C1116 PULLUP_N_BLEED_4 PULLUP_N_BLEED_6 0.00855f
C1117 TERM_VCM FS_P_BLEED_1 0.03472f
C1118 HS_N_7 PULLUP_P_BLEED_5 0.03702f
C1119 TERM_OR_P_B TERM_GATE_P 12.9405f
C1120 TERM_VCM PULLDOWN_P_R 0.22328f
C1121 PULLUP_P_OUT TERM_GATE_P_BLEED_2 0.04242f
C1122 HS_N_11 HS_P_13 0.02487f
C1123 HS_P_11 PULLUP_P_OUT 0.05519f
C1124 FS_LOW_N PULLUP_P_BLEED_5 0.02437f
C1125 PULLUP_P_OUT FS_P_BLEED_0 0.11038f
C1126 PULLUP_P_BLEED_3 HS_N_3 0.03489f
C1127 TERM_ENABLE FS_P_BLEED_1 0.05902f
C1128 TERM_GATE_N TERM_OR_N_S 0.0189f
C1129 TERM_ENABLE PULLDOWN_P_R 0.08114f
C1130 PULLUP_N_GATE TERM_P_R 0.15782f
C1131 PULLUP_P_BLEED_5 TERM_OR_N_NS 0
C1132 HS_N_8 HS_P_11 0.02857f
C1133 RX_N FS_N_OUT 0.01566f
C1134 HS_N_7 HS_P_5 0.03489f
C1135 HS_N HS_N_10 3.58671f
C1136 FS_P_OUT RX_P 0.01238f
C1137 TERM_GATE_P_BLEED_0 TERM_N_R 0.14463f
C1138 TERM_OR_P_B HS_N_6 0.07211f
C1139 HS_N_8 FS_P_BLEED_0 0.06178f
C1140 TERM_N_R FS_N_BLEED_2 0.05729f
C1141 PULLUP_P_BLEED_2 PULLUP_P_GATE 0.1764f
C1142 DIV_N TERM_GATE_N_BLEED_0 0.10151f
C1143 HS_N FS_N_BLEED_4 0.06151f
C1144 TERM_OR_N_S TERM_P_R 0.30551f
C1145 PULLDOWN_N_R HS_P_7 0.02418f
C1146 FS_N_BLEED_3 VDD 0.5567f
C1147 HS_N_13 HS_N_4 0.14463f
C1148 VCM_LOW_OK HS_N_10 0.05893f
C1149 PULLUP_P_BLEED_3 PULLDOWN_P_R 0.05462f
C1150 TERM_GATE_P_BLEED_0 HS_P_1 0.05525f
C1151 FS_P_BLEED_6 PULLUP_P_OUT 0.15208f
C1152 HS_P_5 PAD_P 1.15443f
C1153 HS_N HS_P_12 0.5567f
C1154 HS_P_6 PAD_N 0.31264f
C1155 HS_N FS_P_GATE 2.29474f
C1156 HS_P FS_P_OUT 0.68531f
C1157 HS_N_0 HS_N_5 0.04157f
C1158 HS_N_12 HS_N_10 0.07075f
C1159 HS_N FS_P_BLEED_5 0.08043f
C1160 FS_P_BLEED_6 HS_N_8 0.06178f
C1161 HS_N_3 FS_N_OUT 0.06167f
C1162 PAD_N HS_N_2 1.16258f
C1163 HS_P_12 VCM_LOW_OK 0.03489f
C1164 HS_N_7 TERM_GATE_P_BLEED_0 0
C1165 VCM_LOW_OK FS_P_GATE 1.23568f
C1166 TERM_VCM PULLDOWN_P 0.18094f
C1167 PULLUP_N_GATE PULLUP_N_WELL 33.5703f
C1168 FS_LOW_N FS_N_BLEED_2 0
C1169 FS_N_BLEED_5 FS_HIGH_N 0.00933f
C1170 HS_N_13 PULLDOWN_N_R 0.06832f
C1171 HS_N FS_P_CONTROL_S 0.04342f
C1172 PULLUP_N_BLEED_3 PULLDOWN_P 0.00326f
C1173 TERM_ENABLE PULLDOWN_P 0.05932f
C1174 FS_N_BLEED_2 FS_N_WELL 0.35588f
C1175 FS_HIGH_P BYPASS_ENABLE 0
C1176 HS_P_6 HS_P_13 0.15959f
C1177 HS_P_11 HS_P_9 0.00817f
C1178 TERM_OR_P_B HS_N_0 0.07497f
C1179 FS_P_OUT PULLUP_N_OUT 0.573f
C1180 TERM_N_R HS_N_10 0.06034f
C1181 HS_P_12 HS_N_12 0.08272f
C1182 HS_N_12 FS_P_GATE 1.03841f
C1183 FS_P_BLEED_1 FS_N_OUT 0.36323f
C1184 HS_N_2 HS_P_13 0.07762f
C1185 TERM_N_R FS_N_BLEED_4 0.06105f
C1186 TERM_GATE_N TERM_GATE_N_BLEED_1 0.42775f
C1187 PULLUP_P_BLEED_6 PULLUP_P_BLEED_5 3.1342f
C1188 HS_N_12 FS_P_BLEED_5 0.06178f
C1189 HS_N_13 FS_P_WELL 1.99138f
C1190 FS_LOW_P HS_P_13 0.04601f
C1191 HS_P_0 TERM_GATE_P 0.25837f
C1192 HS_N_1 PULLUP_P_BLEED_5 0.02451f
C1193 FS_HIGH_N PULLUP_P 0.04377f
C1194 HS_P TERM_GATE_N_BLEED_0 0.03489f
C1195 TERM_VCM PULLUP_P_BLEED_1 0.01882f
C1196 HS_N_3 TERM_GATE_N_BLEED_2 0.02807f
C1197 HS_N_8 HS_P_7 0.09182f
C1198 HS_N_12 FS_P_CONTROL_S 0.03226f
C1199 FS_P_BLEED_4 HS_N_6 0.06231f
C1200 TERM_N_R FS_P_GATE 0.81322f
C1201 HS_P FS_N_BLEED_1 0.08856f
C1202 HS_N_3 HS_PBIAS 1.07017f
C1203 HS_P_5 HS_N_1 0.03489f
C1204 HS_P_0 HS_N_6 0.03737f
C1205 TERM_ENABLE PULLUP_P_BLEED_1 0.07608f
C1206 HS_N_5 HS_P_10 0.03089f
C1207 HS_N_7 HS_N_10 0.03027f
C1208 FS_N_BLEED_1 FS_N_BLEED_0 4.78029f
C1209 HS_N_6 PULLUP_P_WELL 0.12108f
C1210 FS_LOW_N HS_N_10 0.08441f
C1211 HS_P_12 HS_P_1 0.05935f
C1212 TERM_GATE_N HS_N_6 0.04962f
C1213 TERM_OR_N_NS HS_N_10 0.03425f
C1214 TERM_GATE_N_BLEED_0 PULLUP_N_OUT 0.05462f
C1215 HS_N_10 FS_N_WELL 0.00889f
C1216 HS_N_13 PULLUP_P_OUT 0.03489f
C1217 TERM_GATE_P TERM_P_R 26.175f
C1218 FS_LOW_N FS_N_BLEED_4 0.07141f
C1219 HS_N PULLUP_N_GATE 0.16548f
C1220 FS_P_BLEED_1 HS_PBIAS 0.04811f
C1221 FS_N_BLEED_1 PULLUP_N_OUT 0.05216f
C1222 HS_N_13 HS_N_8 0.16699f
C1223 PULLDOWN_P_R HS_PBIAS 0.50594f
C1224 FS_N_BLEED_4 FS_N_WELL 0.01068f
C1225 TERM_OR_P_B HS_P_10 0.09644f
C1226 PULLDOWN_P FS_N_OUT 0.57337f
C1227 PULLUP_P_BLEED_3 PULLUP_P_BLEED_1 0.00855f
C1228 HS_N_10 PAD_P 0.11949f
C1229 HS_N_7 HS_P_12 0.03489f
C1230 HS_N_7 FS_P_GATE 1.04462f
C1231 PULLUP_P PULLUP_P_BLEED_5 0.15607f
C1232 HS_N_6 TERM_P_R 0.0959f
C1233 TERM_VCM FS_N_BLEED_3 0.13759f
C1234 HS_P_4 HS_N_4 0
C1235 HS_N TERM_OR_N_S 0.07589f
C1236 HS_N_7 FS_P_BLEED_5 0.06178f
C1237 DIFF_ENABLE PULLDOWN_N_R 0.23599f
C1238 HS_N_0 FS_P_BLEED_4 0.06178f
C1239 HS_P_9 HS_P_7 0.00206f
C1240 PULLUP_N PULLUP_N_BLEED_1 0.31155f
C1241 TERM_ENABLE FS_N_BLEED_3 0.11535f
C1242 VCM_LOW_OK TERM_OR_N_S 2.91765f
C1243 HS_P_12 PAD_P 1.66835f
C1244 HS_N_3 PULLUP_P_BLEED_4 0.0525f
C1245 HS_N_7 FS_P_CONTROL_S 0.03226f
C1246 HS_N_0 HS_P_0 0.04061f
C1247 HS_P_3 TERM_GATE_P 0.15659f
C1248 PULLUP_N_BLEED_6 TERM_P_R 0.04797f
C1249 HS_N_0 PULLUP_P_WELL 0.24542f
C1250 PULLUP_P_BLEED_5 HS_N_9 0.04943f
C1251 PAD_N FS_P_OUT 1.89403f
C1252 PULLDOWN_P TERM_GATE_N_BLEED_2 0.07928f
C1253 HS_P_4 PULLDOWN_N_R 0.07217f
C1254 PULLUP_P_BLEED_5 PULLUP_P_GATE 0.2056f
C1255 DIV_ENABLE FS_HIGH_P 4.86998f
C1256 HS_N_11 PULLUP_P_BLEED_5 0.02434f
C1257 HS_N_12 TERM_OR_N_S 0.02482f
C1258 TERM_GATE_N HS_N_0 0.05542f
C1259 HS_N_6 HS_P_3 0.03089f
C1260 HS_P_5 HS_N_9 0.06578f
C1261 PULLDOWN_P HS_PBIAS 0.44043f
C1262 TERM_VCM VDD 40.0347f
C1263 FS_P_OUT HS_P_13 0.1275f
C1264 DIV_N HS_N_4 0.03462f
C1265 HS_P_2 HS_P_11 0.00106f
C1266 PULLUP_N_GATE TERM_N_R 0.17473f
C1267 PULLUP_P_BLEED_4 PULLDOWN_P_R 0.09196f
C1268 HS_P_8 TERM_GATE_P 0.15508f
C1269 PULLUP_P FS_N_BLEED_2 0.10124f
C1270 HS_N_11 HS_P_5 0.03489f
C1271 HS_N_0 TERM_P_R 0.10318f
C1272 TERM_ENABLE VDD 12.7935f
C1273 DIV_LOW_N HS_N_10 0.06178f
C1274 PULLUP_N_BLEED_4 PULLUP_N_BLEED_5 3.06975f
C1275 HS_N_1 HS_N_10 0.12635p
C1276 TERM_OR_N_S TERM_N_R 0.12114f
C1277 HS_N_4 TERM_OR_P_NS 0.00196f
C1278 PULLUP_N PULLUP_N_BLEED_4 0.08101f
C1279 m2_42279_124800# a_41005_131825# 0
C1280 PULLUP_N_WELL PULLUP_N_BLEED_6 0.00637f
C1281 HS_N_3 HS_N_5 0.063f
C1282 HS_N TERM_GATE_N_BLEED_1 0.10264f
C1283 TERM_GATE_P_BLEED_0 HS_N_9 0.00105f
C1284 DIV_N PULLDOWN_N_R 0.0471f
C1285 FS_HIGH_N FS_LOW_P 0.11423f
C1286 PULLUP_P_BLEED_3 VDD 0.44664f
C1287 DIV_LOW_P DIV_P 0.50398f
C1288 FS_N_BLEED_5 FS_N_BLEED_4 0.79478f
C1289 HS_P_0 HS_P_10 2.2381f
C1290 HS_P_12 HS_N_1 0.06335f
C1291 HS_N_1 FS_P_GATE 1.0435f
C1292 PULLUP_N_GATE PULLUP_N_CONTROL_S 1.68347f
C1293 PULLDOWN_P PULLUP_N_BLEED_1 0.06517f
C1294 FS_P_BLEED_2 FS_N_OUT 0.15927f
C1295 FS_LOW_N PULLUP_N_GATE 0.17511f
C1296 PULLDOWN_P FS_N_GATE 1.24942f
C1297 HS_N_0 HS_P_3 0.02686f
C1298 HS_P_4 PULLUP_P_OUT 0.05519f
C1299 PULLDOWN_N_R TERM_OR_P_NS 0.04591f
C1300 HS_N_1 FS_P_BLEED_5 0.06178f
C1301 a_44789_117064# a_43813_117064# 2.94235f
C1302 FS_HIGH_N PULLUP_N_BLEED_0 0.00933f
C1303 HS_N_5 PULLDOWN_P_R 0.02404f
C1304 FS_P_BLEED_1 HS_N_5 0.03472f
C1305 TERM_OR_P_B HS_N_3 0.07211f
C1306 HS_N_7 TERM_OR_N_S 0.02895f
C1307 HS_P_4 HS_N_8 0.02404f
C1308 HS_N TERM_GATE_P 0.17562f
C1309 ESD_RAIL a_41684_148611# 1.21921p
C1310 TERM_OR_N_S FS_LOW_N 0.4405f
C1311 DIV_N FS_P_WELL 0.86039f
C1312 PULLUP_P HS_N_10 0.02404f
C1313 HS_N_1 FS_P_CONTROL_S 0.0324f
C1314 HS_N_12 TERM_GATE_N_BLEED_1 0.05263f
C1315 TERM_OR_N_S TERM_OR_N_NS 0.00164f
C1316 HS_N_2 PULLUP_P_BLEED_5 0.02404f
C1317 VCM_LOW_OK TERM_GATE_P 0.20188f
C1318 HS_P_6 HS_P_5 32.3343f
C1319 HS_P_10 TERM_P_R 0.14229f
C1320 FS_N_BLEED_4 PULLUP_P 0.05445f
C1321 HS_N HS_N_6 7.99416f
C1322 VDD FS_N_OUT 11.0129f
C1323 TERM_OR_P_B PULLDOWN_P_R 0.17949f
C1324 HS_P HS_N_4 0.33321f
C1325 HS_P_5 HS_N_2 0.03489f
C1326 DIV_LOW_P BYPASS_ENABLE 0
C1327 HS_P_2 HS_P_7 0.06184f
C1328 HS_P PULLUP_N_BLEED_2 0.00212f
C1329 VCM_LOW_OK HS_N_6 0.05893f
C1330 FS_N_BLEED_3 HS_PBIAS 0.08856f
C1331 TERM_GATE_N_BLEED_1 TERM_N_R 0.07874f
C1332 HS_N_9 HS_N_10 0.03655f
C1333 HS_N_12 TERM_GATE_P 0.10814f
C1334 DIV_N PULLUP_P_OUT 0
C1335 HS_N PULLUP_N_BLEED_6 0.06167f
C1336 PULLDOWN_P PULLUP_N_BLEED_4 0
C1337 HS_P_5 FS_LOW_P 0.17341f
C1338 PULLUP_P_GATE HS_N_10 0.08357f
C1339 HS_N_11 HS_N_10 0.13802p
C1340 DIV_N HS_N_8 0.03462f
C1341 HS_N_12 HS_N_6 0
C1342 DIFF_ENABLE BYPASS_ENABLE 5.18795f
C1343 HS_N_4 PULLUP_N_OUT 0.01742f
C1344 PULLUP_P_OUT TERM_OR_P_NS 0.1011f
C1345 HS_P_6 TERM_GATE_P_BLEED_0 0.02404f
C1346 HS_P_3 HS_P_10 0.02866f
C1347 PULLDOWN_P HS_N_5 0.04428f
C1348 HS_P PULLDOWN_N_R 0.08383f
C1349 HS_P_4 HS_P_9 0.042f
C1350 TERM_N_R TERM_GATE_P 1.39719f
C1351 HS_P_12 HS_N_9 0.06578f
C1352 HS_N_8 TERM_OR_P_NS 0.00704f
C1353 HS_N_9 FS_P_GATE 1.05196f
C1354 FS_N_BLEED_0 PULLDOWN_N_R 0.05188f
C1355 FS_P_BLEED_5 HS_N_9 0.06178f
C1356 VDD HS_PBIAS 83.74921f
C1357 HS_N HS_N_0 0.13467p
C1358 PULLUP_P_GATE FS_P_GATE 0.53486f
C1359 TERM_VCM TERM_ENABLE 0.55788f
C1360 HS_N_7 TERM_GATE_N_BLEED_1 0.0525f
C1361 DIV_N DIV_P 48.6079f
C1362 HS_N_11 FS_P_GATE 1.0396f
C1363 HS_N_13 DIV_ENABLE 0.03089f
C1364 FS_P_BLEED_5 PULLUP_P_GATE 0.01836f
C1365 FS_N_BLEED_3 FS_N_GATE 0.19336f
C1366 HS_N_11 HS_P_12 0.06914f
C1367 HS_N_6 TERM_N_R 0.1093f
C1368 FS_LOW_N TERM_GATE_N_BLEED_1 0.0839f
C1369 FS_N_BLEED_2 FS_LOW_P 0.14463f
C1370 HS_N_3 FS_P_BLEED_4 0.06178f
C1371 HS_N_11 FS_P_BLEED_5 0.06178f
C1372 TERM_ENABLE PULLUP_N_BLEED_3 0.01168f
C1373 FS_HIGH_P FS_P_BLEED_0 0.23079f
C1374 TERM_GATE_P HS_P_1 0.25434f
C1375 HS_P FS_P_WELL 2.08315f
C1376 FS_P_CONTROL_S HS_N_9 0.03242f
C1377 VCM_LOW_OK HS_N_0 0.05893f
C1378 HS_P_8 HS_P_10 0.00926f
C1379 PULLUP_N_OUT PULLDOWN_N_R 0.08331f
C1380 TERM_OR_N_S HS_N_1 0.02599f
C1381 FS_N_BLEED_5 PULLUP_N_GATE 0
C1382 PULLUP_P_BLEED_0 PULLDOWN_P_R 0.01291f
C1383 HS_N_3 PULLUP_P_WELL 0.11601f
C1384 HS_N_11 FS_P_CONTROL_S 0.03234f
C1385 TERM_VCM PULLUP_P_BLEED_3 0.03472f
C1386 HS_N_7 TERM_GATE_P 0.12198f
C1387 HS_N_6 HS_P_1 0.03099f
C1388 TERM_N_R PULLUP_N_BLEED_6 0.06125f
C1389 TERM_GATE_N HS_N_3 0.04808f
C1390 FS_P_BLEED_4 PULLDOWN_P_R 0.08089f
C1391 TERM_ENABLE PULLUP_P_BLEED_3 0.05997f
C1392 HS_N_12 HS_N_0 0.04188f
C1393 HS_P_6 HS_N_10 0.0597f
C1394 HS_N_7 HS_N_6 0.12041p
C1395 PULLUP_N_OUT FS_P_WELL 2.65652f
C1396 HS_P_0 PULLDOWN_P_R 0.03037f
C1397 HS_P PULLUP_P_OUT 0.03526f
C1398 HS_P_9 TERM_OR_P_NS 0.03937f
C1399 FS_LOW_N HS_N_6 0.08478f
C1400 PULLDOWN_P_R PULLUP_P_WELL 0.59282f
C1401 FS_N_GATE VDD 23.571f
C1402 FS_P_BLEED_1 PULLUP_P_WELL 0.00137f
C1403 PULLUP_N_BLEED_5 TERM_P_R 0.11141f
C1404 HS_N_3 TERM_P_R 0.05893f
C1405 DIV_P RX_P 1.39534f
C1406 FS_P_BLEED_6 FS_P_BLEED_3 0.12236f
C1407 DIV_N BYPASS_ENABLE 0.09436f
C1408 HS_N_2 HS_N_10 0.03509f
C1409 HS_N_6 TERM_OR_N_NS 0.03425f
C1410 HS_P HS_N_8 0.55444f
C1411 PULLUP_N_GATE PULLUP_P 1.42018f
C1412 HS_N_0 TERM_N_R 0.13438f
C1413 PULLUP_N TERM_P_R 0.07457f
C1414 HS_N HS_P_10 0.34498f
C1415 FS_LOW_P HS_N_10 0.08505f
C1416 FS_N_BLEED_1 FS_HIGH_N 0.01132f
C1417 HS_N_6 PAD_P 2.14046f
C1418 HS_P_6 HS_P_12 0.07018f
C1419 PULLUP_P_CONTROL_S HS_N_10 0.04949f
C1420 TERM_VCM FS_N_OUT 0.42885f
C1421 HS_P_5 FS_P_OUT 0.05462f
C1422 FS_LOW_N PULLUP_N_BLEED_6 0.06798f
C1423 TERM_OR_N_S PULLUP_P 0.13572f
C1424 DIV_ENABLE DIV_LOW_P 2.67093f
C1425 FS_N_BLEED_4 FS_LOW_P 0.23267f
C1426 PULLUP_N_OUT PULLUP_P_OUT 0.17355f
C1427 PAD_N HS_N_4 1.29614f
C1428 TERM_ENABLE FS_N_OUT 0.47587f
C1429 VCM_LOW_OK HS_P_10 0.09044f
C1430 PULLDOWN_P_R TERM_P_R 0.16322f
C1431 HS_P_12 HS_N_2 0.06578f
C1432 FS_P_BLEED_1 TERM_P_R 0.04766f
C1433 HS_P DIV_P 0.08005f
C1434 a_41005_134065# m2_42279_124800# 0
C1435 HS_N_8 PULLUP_N_OUT 0.01067f
C1436 HS_N_2 FS_P_GATE 1.03585f
C1437 HS_N_2 FS_P_BLEED_5 0.06178f
C1438 HS_N_3 HS_P_3 0.03733f
C1439 DIV_ENABLE DIFF_ENABLE 5.44387f
C1440 FS_LOW_P FS_P_GATE 0.55919f
C1441 HS_N_1 TERM_GATE_N_BLEED_1 0.05286f
C1442 HS_P_12 FS_LOW_P 0.17418f
C1443 TERM_OR_N_S HS_N_9 0.03405f
C1444 HS_N_7 HS_N_0 0.07359f
C1445 PULLUP_N_BLEED_4 VDD 0.0157f
C1446 HS_N_12 HS_P_10 0.04371f
C1447 HS_N_4 HS_P_13 0.02957f
C1448 PULLUP_P_BLEED_3 FS_N_OUT 0.06167f
C1449 HS_N_2 FS_P_CONTROL_S 0.03226f
C1450 RX_P BYPASS_ENABLE 4.97887f
C1451 HS_N_0 FS_LOW_N 0.08452f
C1452 PULLUP_N PULLUP_N_WELL 0.61243f
C1453 HS_P_4 HS_P_2 0.03986f
C1454 PAD_N PULLDOWN_N_R 4.48191f
C1455 HS_P HS_P_9 6.36218f
C1456 HS_N_11 TERM_OR_N_S 0.02508f
C1457 TERM_VCM TERM_GATE_N_BLEED_2 0.02153f
C1458 HS_N_0 TERM_OR_N_NS 0.03425f
C1459 PULLUP_P_BLEED_1 PULLUP_P_BLEED_0 0.83843f
C1460 HS_P_11 HS_P_7 0.0963f
C1461 HS_N_5 VDD 6.46267f
C1462 HS_P_3 PULLDOWN_P_R 0.07466f
C1463 HS_N_1 TERM_GATE_P 0.10974f
C1464 TERM_GATE_N PULLDOWN_P 0.15548f
C1465 TERM_ENABLE TERM_GATE_N_BLEED_2 0.07928f
C1466 HS_N_0 PAD_P 0.14558f
C1467 TERM_VCM HS_PBIAS 0.70648f
C1468 TERM_N_R HS_P_10 0.05037f
C1469 PULLUP_P_BLEED_6 HS_N_6 0
C1470 HS_N_13 FS_HIGH_P 0.02404f
C1471 DIV_LOW_N HS_N_6 0.06178f
C1472 TERM_ENABLE HS_PBIAS 0.73653f
C1473 PULLDOWN_N_R HS_P_13 0.02404f
C1474 HS_N_13 FS_P_BLEED_3 0.02846f
C1475 PULLDOWN_P TERM_P_R 0.04141f
C1476 PULLUP_N_OUT HS_P_9 0.07928f
C1477 TERM_OR_P_B VDD 16.0128f
C1478 a_41005_133505# ESD_RAIL 0.53842f
C1479 HS_P_10 HS_P_1 37.0279f
C1480 TERM_GATE_N_BLEED_1 PULLUP_P 0.09196f
C1481 PULLUP_P_BLEED_1 PULLUP_P_WELL 0.15492f
C1482 PULLDOWN_P_R HS_P_8 0.08554f
C1483 HS_N_13 FS_P_BLEED_0 0.06178f
C1484 PULLUP_P_BLEED_3 HS_PBIAS 0.04828f
C1485 DIV_N DIV_ENABLE 33.0875f
C1486 FS_P_WELL HS_P_13 0.19945f
C1487 HS_N_7 HS_P_10 0
C1488 FS_P_OUT HS_N_10 0.44249f
C1489 TERM_VCM FS_N_GATE 0.90423f
C1490 a_41005_132945# a_41005_133505# 0.0346f
C1491 FS_N_BLEED_1 FS_N_BLEED_2 6.33216f
C1492 TERM_GATE_N_BLEED_1 HS_N_9 0.0525f
C1493 PAD_N PULLUP_P_OUT 0.20908f
C1494 HS_P_2 TERM_OR_P_NS 0.02846f
C1495 PULLUP_N_BLEED_3 PULLUP_N_BLEED_1 0.06528f
C1496 HS_N HS_N_3 2.40305f
C1497 PULLUP_P_BLEED_1 TERM_P_R 0.04588f
C1498 TERM_ENABLE FS_N_GATE 0.97699f
C1499 PAD_N HS_N_8 1.07245f
C1500 TERM_OR_N_S TERM_OR_N_B 4.08319f
C1501 HS_N_11 TERM_GATE_N_BLEED_1 0.05266f
C1502 PULLUP_N_GATE FS_LOW_P 0.10761f
C1503 PULLDOWN_P PULLUP_N_WELL 0.47103f
C1504 DIV_LOW_N HS_N_0 0.06837f
C1505 VCM_LOW_OK HS_N_3 0.05893f
C1506 HS_N_6 PULLUP_P 0.07466f
C1507 HS_N_13 FS_P_BLEED_6 0.06178f
C1508 HS_N_2 TERM_OR_N_S 0.02451f
C1509 HS_P_10 PAD_P 1.26307f
C1510 HS_N_0 HS_N_1 0.12498p
C1511 FS_P_BLEED_4 FS_P_BLEED_2 0.12224f
C1512 HS_P_12 FS_P_OUT 0.10923f
C1513 FS_P_OUT FS_P_GATE 0.13406p
C1514 HS_N_9 TERM_GATE_P 0.13605f
C1515 HS_PBIAS FS_N_OUT 0.93576f
C1516 HS_N PULLDOWN_P_R 0.04388f
C1517 HS_N FS_P_BLEED_1 0.04405f
C1518 PULLUP_N_GATE PULLUP_N_BLEED_0 0.05192f
C1519 HS_N_8 HS_P_13 0.04828f
C1520 PAD_N DIV_P 0.47479f
C1521 FS_P_BLEED_2 PULLUP_P_WELL 0
C1522 PULLUP_P PULLUP_N_BLEED_6 0.05764f
C1523 HS_N_12 HS_N_3 0.03984f
C1524 PULLUP_P_BLEED_0 VDD 0.05459f
C1525 HS_N_6 HS_N_9 0.04101f
C1526 FS_P_BLEED_1 VCM_LOW_OK 0.0381f
C1527 HS_N_11 TERM_GATE_P 0.10852f
C1528 VCM_LOW_OK PULLDOWN_P_R 0.06553f
C1529 DIV_ENABLE RX_P 0.88297f
C1530 FS_HIGH_P DIFF_ENABLE 0.2074f
C1531 FS_P_OUT FS_P_CONTROL_S 0
C1532 TERM_VCM PULLUP_N_BLEED_4 0.02041f
C1533 PULLUP_P_BLEED_3 PULLUP_P_BLEED_4 6.29036f
C1534 TERM_GATE_N_BLEED_0 HS_N_10 0.03489f
C1535 HS_N_6 PULLUP_P_GATE 0.08451f
C1536 FS_N_BLEED_3 TERM_P_R 0.11141f
C1537 HS_N_11 HS_N_6 0
C1538 PULLUP_N_BLEED_3 PULLUP_N_BLEED_4 1.53214f
C1539 HS_N_3 TERM_N_R 0.05893f
C1540 TERM_ENABLE PULLUP_N_BLEED_4 0.08954f
C1541 TERM_N_R PULLUP_N_BLEED_5 0.11444f
C1542 FS_N_BLEED_1 FS_N_BLEED_4 0.0078f
C1543 HS_P HS_P_2 7.07711f
C1544 HS_N_12 PULLDOWN_P_R 0.02424f
C1545 HS_P_0 VDD 3.95338f
C1546 FS_P_BLEED_1 HS_N_12 0.03472f
C1547 TERM_VCM HS_N_5 0.12535f
C1548 PAD_N HS_P_9 6.47937f
C1549 PULLUP_N TERM_N_R 0.12734f
C1550 TERM_GATE_P_BLEED_1 PULLDOWN_N_R 0.00195f
C1551 PULLUP_P_WELL VDD 30.3758f
C1552 TERM_GATE_N_BLEED_2 HS_PBIAS 0.17672f
C1553 HS_P DIV_ENABLE 0.03818f
C1554 HS_P FS_N_CONTROL_S 0.09439f
C1555 HS_N_0 PULLUP_P 0.07466f
C1556 TERM_ENABLE HS_N_5 0.08996f
C1557 FS_N_GATE FS_N_OUT 0.14435p
C1558 TERM_GATE_N VDD 3.74877f
C1559 DIFF_ENABLE PULLDOWN_N 0.37137f
C1560 RX_N PAD_P 0.47227f
C1561 PAD_N BYPASS_ENABLE 11.6747f
C1562 HS_N_1 HS_P_10 0.0348f
C1563 TERM_VCM TERM_OR_P_B 0.06482f
C1564 FS_P_BLEED_1 TERM_N_R 0.06105f
C1565 PULLUP_P_BLEED_4 FS_N_OUT 0.06408f
C1566 HS_P_9 HS_P_13 0.04877f
C1567 HS_N_2 TERM_GATE_N_BLEED_1 0.0525f
C1568 HS_P_2 PULLUP_N_OUT 0.07964f
C1569 ESD_RAIL a_53878_131545# 0.56772f
C1570 FS_HIGH_N PULLDOWN_N_R 0.03743f
C1571 TERM_ENABLE TERM_OR_P_B 5.36669f
C1572 VDD TERM_P_R 6.53315f
C1573 HS_N_7 HS_N_3 0.06865f
C1574 HS_N_0 HS_N_9 0.04157f
C1575 VCM_LOW_OK PULLDOWN_P 0.04528f
C1576 HS_P_4 HS_P_11 0
C1577 PULLUP_P_BLEED_3 HS_N_5 0.03489f
C1578 TERM_GATE_N_BLEED_1 FS_LOW_P 0.05872f
C1579 DIV_ENABLE PULLUP_N_OUT 0.05062f
C1580 FS_N_BLEED_3 PULLUP_N_WELL 0
C1581 PULLUP_N_OUT FS_N_CONTROL_S 0.10706f
C1582 HS_P_6 TERM_GATE_P 0.15508f
C1583 HS_N_0 PULLUP_P_GATE 0.08394f
C1584 PULLDOWN_P_R HS_P_1 0.08595f
C1585 HS_N_3 FS_LOW_N 0.08441f
C1586 PULLUP_N PULLUP_N_CONTROL_S 1.30292f
C1587 HS_N_11 HS_N_0 0.0421f
C1588 HS_N_4 PULLUP_P_BLEED_5 0.02921f
C1589 HS_N_3 TERM_OR_N_NS 0.03425f
C1590 HS_P_6 HS_N_6 0.06938f
C1591 HS_N_2 TERM_GATE_P 0.10747f
C1592 HS_N_12 PULLDOWN_P 0.04428f
C1593 DIV_N FS_HIGH_P 8.67054f
C1594 HS_N_3 PAD_P 0.09104f
C1595 HS_P_5 HS_N_4 0.03511f
C1596 PULLUP_N_BLEED_1 HS_PBIAS 0.17672f
C1597 HS_N_7 PULLDOWN_P_R 0.02404f
C1598 HS_N_7 FS_P_BLEED_1 0.03472f
C1599 FS_LOW_P TERM_GATE_P 0.15357f
C1600 FS_N_GATE HS_PBIAS 3.08633f
C1601 TERM_GATE_P_BLEED_1 PULLUP_P_OUT 0.14929f
C1602 HS_N_2 HS_N_6 0
C1603 FS_LOW_N PULLDOWN_P_R 0.00223f
C1604 HS_P_3 VDD 6.14484f
C1605 VCM_LOW_OK PULLUP_P_BLEED_1 0.01462f
C1606 PULLUP_P_BLEED_4 HS_PBIAS 0.07928f
C1607 PULLDOWN_N_R PULLUP_P_BLEED_5 0.09196f
C1608 HS_N_6 FS_LOW_P 0.08542f
C1609 PULLUP_N_WELL VDD 25.2292f
C1610 HS_N_6 PULLUP_P_CONTROL_S 0.04808f
C1611 PULLDOWN_P TERM_N_R 0.20782f
C1612 PULLDOWN_P_R PAD_P 2.92129f
C1613 HS_P_5 PULLDOWN_N_R 0.02411f
C1614 HS_P_11 TERM_OR_P_NS 0.04285f
C1615 HS_P_10 HS_N_9 0.03109f
C1616 HS_P_8 VDD 4.99906f
C1617 HS_N_13 DIV_LOW_P 0.00103f
C1618 PULLUP_N_BLEED_6 FS_LOW_P 0.06116f
C1619 TERM_OR_P_B FS_N_OUT 0.05082f
C1620 TERM_ENABLE PULLUP_P_BLEED_0 0.00606f
C1621 HS_N FS_N_BLEED_3 0.11535f
C1622 HS_N_11 HS_P_10 0.1403f
C1623 HS_P_6 HS_N_0 0.06114f
C1624 HS_P_4 HS_P_7 0.06067f
C1625 TERM_OR_N_S TERM_GATE_N_BLEED_0 0
C1626 TERM_VCM HS_P_0 0.19537f
C1627 HS_N_7 PULLDOWN_P 0.04428f
C1628 HS_N_5 TERM_GATE_N_BLEED_2 0.03089f
C1629 TERM_N_R PULLUP_P_BLEED_1 0.05729f
C1630 PULLUP_N_BLEED_6 PULLUP_N_BLEED_0 0.00257f
C1631 HS_N FS_P_BLEED_2 0.01113f
C1632 TERM_VCM PULLUP_P_WELL 0.28547f
C1633 DIV_LOW_N HS_N_3 0.06178f
C1634 PAD_N HS_P_2 2.43754f
C1635 HS_N_2 HS_N_0 0.04171f
C1636 PULLDOWN_P FS_LOW_N 0.32402f
C1637 HS_N_3 HS_N_1 0.03945f
C1638 PULLUP_P_BLEED_3 PULLUP_P_BLEED_0 0.0078f
C1639 PULLDOWN_N_R FS_N_BLEED_2 0.08856f
C1640 TERM_ENABLE HS_P_0 0.03037f
C1641 HS_N_5 HS_PBIAS 4.87448f
C1642 PULLDOWN_P TERM_OR_N_NS 0.04764f
C1643 TERM_GATE_P_BLEED_0 PULLDOWN_N_R 0.0553f
C1644 TERM_ENABLE PULLUP_P_WELL 2.34229f
C1645 PULLDOWN_P FS_N_WELL 2.59822f
C1646 HS_P FS_HIGH_P 0.02404f
C1647 DIV_ENABLE PAD_N 0.03382f
C1648 HS_N_0 FS_LOW_P 0.08516f
C1649 m2_42279_124800# a_41005_131545# 0.05457f
C1650 TERM_VCM TERM_GATE_N 24.8972f
C1651 HS_N_0 PULLUP_P_CONTROL_S 0.05093f
C1652 HS_P FS_P_BLEED_3 0.0834f
C1653 FS_HIGH_P FS_N_BLEED_0 0.00106f
C1654 HS_P_2 HS_P_13 36.317f
C1655 a_41005_132385# ESD_RAIL 0.53823f
C1656 PULLUP_P_BLEED_6 PULLDOWN_P_R 0.19409f
C1657 TERM_ENABLE TERM_GATE_N 10.756f
C1658 HS_N_8 PULLUP_P_BLEED_5 0.04243f
C1659 TERM_VCM TERM_P_R 0.19926p
C1660 HS_N VDD 2.60831f
C1661 FS_P_BLEED_1 HS_N_1 0.03472f
C1662 HS_P HS_P_11 5.65023f
C1663 HS_N_12 FS_P_BLEED_2 0
C1664 HS_N_1 PULLDOWN_P_R 0.02445f
C1665 PULLUP_P_BLEED_3 PULLUP_P_WELL 0.00303f
C1666 HS_N_4 HS_N_10 0
C1667 HS_P FS_P_BLEED_0 0.06178f
C1668 FS_HIGH_P PULLUP_N_OUT 0.05082f
C1669 TERM_ENABLE TERM_P_R 0.46656f
C1670 HS_P_5 HS_N_8 0.05893f
C1671 VCM_LOW_OK VDD 57.507f
C1672 FS_P_OUT TERM_GATE_P 0.22814f
C1673 HS_P PULLDOWN_N 0.03743f
C1674 FS_N_BLEED_3 TERM_N_R 0.11444f
C1675 a_41005_132385# a_41005_132945# 0.0346f
C1676 HS_P_6 HS_P_10 0.07646f
C1677 FS_HIGH_N BYPASS_ENABLE 0
C1678 PULLUP_P PULLUP_N_BLEED_5 0.10721f
C1679 TERM_OR_P_NS HS_P_7 0.02846f
C1680 HS_N_3 PULLUP_P 0.02404f
C1681 FS_P_OUT HS_N_6 0.43331f
C1682 HS_P_12 HS_N_4 0.07181f
C1683 HS_N_2 HS_P_10 0.03089f
C1684 FS_P_BLEED_4 FS_N_OUT 0.06639f
C1685 HS_P_11 PULLUP_N_OUT 0.08824f
C1686 HS_N_12 VDD 6.63266f
C1687 PULLUP_N PULLUP_P 0.03743f
C1688 PULLUP_N_OUT FS_P_BLEED_0 0.11535f
C1689 HS_N_4 FS_P_GATE 1.03504f
C1690 HS_N_4 FS_P_BLEED_5 0.06178f
C1691 PULLUP_P_BLEED_3 TERM_P_R 0.04766f
C1692 HS_P FS_P_BLEED_6 0.06178f
C1693 TERM_VCM HS_P_3 0.12019f
C1694 TERM_GATE_N_BLEED_0 TERM_GATE_N_BLEED_1 7.21575f
C1695 PULLDOWN_N_R HS_N_10 0.02404f
C1696 PULLUP_P_BLEED_4 HS_N_5 0.0525f
C1697 TERM_GATE_P_BLEED_0 PULLUP_P_OUT 0.1011f
C1698 DIV_N HS_N_13 0.03462f
C1699 PULLUP_P_WELL FS_N_OUT 0.13784f
C1700 FS_N_BLEED_4 PULLDOWN_N_R 0.04811f
C1701 HS_P_10 FS_LOW_P 0.05509f
C1702 TERM_VCM PULLUP_N_WELL 0.36125f
C1703 TERM_GATE_P_BLEED_0 HS_N_8 0
C1704 PULLUP_P_BLEED_6 PULLDOWN_P 0.09848f
C1705 TERM_ENABLE HS_P_3 0.0768f
C1706 PULLUP_P PULLDOWN_P_R 0.09196f
C1707 HS_N_3 HS_N_9 0.03256f
C1708 DIV_LOW_N PULLDOWN_P 0.08856f
C1709 PULLUP_N_BLEED_3 PULLUP_N_WELL 0
C1710 TERM_ENABLE PULLUP_N_WELL 0.52247f
C1711 HS_N_4 FS_P_CONTROL_S 0.03226f
C1712 HS_N_3 PULLUP_P_GATE 0.08296f
C1713 TERM_N_R VDD 6.88046f
C1714 TERM_GATE_N FS_N_OUT 0.05082f
C1715 FS_N_BLEED_3 FS_LOW_N 0
C1716 HS_P_12 PULLDOWN_N_R 0.02404f
C1717 PULLDOWN_N_R FS_P_GATE 1.47723f
C1718 FS_P_BLEED_6 PULLUP_N_OUT 0.11535f
C1719 FS_N_BLEED_3 FS_N_WELL 0.1181f
C1720 HS_P_5 HS_P_9 0
C1721 TERM_VCM HS_P_8 0.09675f
C1722 FS_P_WELL HS_N_10 2.06442f
C1723 HS_N_11 HS_N_3 0.03962f
C1724 FS_P_BLEED_5 PULLDOWN_N_R 0.10378f
C1725 PULLDOWN_P_R HS_N_9 0.02404f
C1726 FS_P_BLEED_1 HS_N_9 0.03472f
C1727 VDD HS_P_1 5.54122f
C1728 a_53878_134345# ESD_RAIL 0.5677f
C1729 TERM_ENABLE HS_P_8 0.02404f
C1730 TERM_P_R FS_N_OUT 0.3082f
C1731 TERM_GATE_N_BLEED_0 HS_N_6 0.03489f
C1732 HS_N_0 FS_P_OUT 0.5609f
C1733 FS_P_BLEED_1 PULLUP_P_GATE 0.00424f
C1734 PULLDOWN_P_R PULLUP_P_GATE 0.39874f
C1735 FS_P_BLEED_4 HS_PBIAS 0.09926f
C1736 HS_P HS_P_7 0.53303f
C1737 HS_N_11 FS_P_BLEED_1 0.03472f
C1738 HS_N_11 PULLDOWN_P_R 0.02429f
C1739 HS_P_0 HS_PBIAS 0.94883f
C1740 HS_P_12 FS_P_WELL 0.00134f
C1741 FS_P_WELL FS_P_GATE 0.26394p
C1742 HS_N_7 VDD 5.51673f
C1743 PULLUP_P_OUT HS_N_10 0.03489f
C1744 PULLUP_N_CONTROL_S VDD 0.68736f
C1745 PULLUP_P_WELL HS_PBIAS 0.52241f
C1746 TERM_GATE_N TERM_GATE_N_BLEED_2 0.42751f
C1747 FS_LOW_N VDD 2.24181f
C1748 TERM_GATE_P_BLEED_0 HS_P_9 0.03888f
C1749 HS_N_8 HS_N_10 0.04444f
C1750 PULLDOWN_P PULLUP_P 0.05412f
C1751 DIV_N DIV_LOW_P 0.89345f
C1752 TERM_OR_N_NS VDD 0.44386f
C1753 VDD FS_N_WELL 0.10242p
C1754 TERM_OR_P_B HS_N_5 0.07211f
C1755 TERM_GATE_N HS_PBIAS 0.13841f
C1756 FS_P_CONTROL_S FS_P_WELL 0.18587f
C1757 PULLUP_N_OUT HS_P_7 0.02846f
C1758 VDD PAD_P 0
C1759 TERM_VCM HS_N 0.21341f
C1760 HS_N_13 HS_P 0.10519f
C1761 PULLUP_P_OUT FS_P_GATE 1.53435f
C1762 PULLUP_N_BLEED_2 PULLUP_N_GATE 0.06702f
C1763 PAD_N HS_P_11 1.42473f
C1764 HS_P_6 HS_N_3 0.05828f
C1765 HS_N TERM_ENABLE 0.07737f
C1766 TERM_P_R HS_PBIAS 0.44602f
C1767 FS_P_BLEED_5 PULLUP_P_OUT 0.05047f
C1768 TERM_VCM VCM_LOW_OK 0.10492p
C1769 HS_N_8 FS_P_GATE 1.04761f
C1770 DIV_ENABLE FS_HIGH_N 3.66887f
C1771 FS_HIGH_N FS_N_CONTROL_S 7.6088f
C1772 TERM_OR_N_S HS_N_4 0.026f
C1773 HS_P_12 HS_N_8 0.06335f
C1774 HS_N_0 TERM_GATE_N_BLEED_0 0.03489f
C1775 FS_P_BLEED_5 HS_N_8 0.06178f
C1776 PULLDOWN_P PULLUP_P_GATE 0.02056f
C1777 HS_N_2 HS_N_3 0.12365p
C1778 TERM_ENABLE VCM_LOW_OK 0.27311f
C1779 HS_N_11 PULLDOWN_P 0.05266f
C1780 PULLUP_P PULLUP_P_BLEED_1 0.23767f
C1781 HS_P_11 HS_P_13 0.08851f
C1782 HS_N_13 PULLUP_N_OUT 0.05062f
C1783 HS_N_3 FS_LOW_P 0.08505f
C1784 FS_P_BLEED_2 HS_N_1 0
C1785 HS_N PULLUP_P_BLEED_3 0.04828f
C1786 HS_N_3 PULLUP_P_CONTROL_S 0.04808f
C1787 PULLUP_N_GATE PULLDOWN_N_R 0.15922f
C1788 HS_P_6 PULLDOWN_P_R 0.02404f
C1789 TERM_VCM HS_N_12 0.12019f
C1790 HS_N_8 FS_P_CONTROL_S 0.03238f
C1791 HS_P_12 DIV_P 0.03388f
C1792 PULLUP_P_BLEED_4 PULLUP_P_WELL 0
C1793 TERM_ENABLE HS_N_12 0.08984f
C1794 FS_N_BLEED_5 FS_N_BLEED_3 0
C1795 TERM_OR_N_S PULLDOWN_N_R 0.08196f
C1796 a_41005_131545# a_43813_117064# 2.2693f
C1797 HS_N_2 PULLDOWN_P_R 0.02404f
C1798 HS_P_3 HS_PBIAS 6.23881f
C1799 FS_P_BLEED_1 HS_N_2 0.03472f
C1800 PULLUP_P_BLEED_3 VCM_LOW_OK 0.03823f
C1801 TERM_VCM TERM_N_R 17.5283f
C1802 PULLUP_N_WELL HS_PBIAS 0.42834f
C1803 HS_P_4 TERM_OR_P_NS 0.02846f
C1804 FS_N_GATE TERM_P_R 0.72109f
C1805 PULLUP_N PULLUP_N_BLEED_0 0.85278f
C1806 FS_P_BLEED_1 FS_LOW_P 0.07139f
C1807 PULLUP_P_CONTROL_S PULLDOWN_P_R 0.08753f
C1808 PULLDOWN_P_R FS_LOW_P 0.06539f
C1809 PULLUP_P_BLEED_1 PULLUP_P_GATE 0.19163f
C1810 ESD_RAIL a_53878_132665# 0.53916f
C1811 HS_P_5 HS_P_2 0.03142f
C1812 DIV_LOW_N VDD 0.25658f
C1813 PULLUP_P_BLEED_3 HS_N_12 0.03489f
C1814 HS_N_1 VDD 4.91737f
C1815 TERM_ENABLE TERM_N_R 0.4835f
C1816 FS_N_BLEED_4 BYPASS_ENABLE 0.00766f
C1817 FS_N_BLEED_3 PULLUP_P 0.10124f
C1818 HS_N FS_N_OUT 1.15664f
C1819 DIV_ENABLE HS_P_5 0.00252f
C1820 TERM_VCM HS_P_1 0.15005f
C1821 FS_P_BLEED_4 HS_N_5 0.06219f
C1822 HS_P_8 HS_PBIAS 1.54227f
C1823 FS_N_BLEED_5 VDD 0.00257f
C1824 HS_P_0 HS_N_5 0.03733f
C1825 HS_P DIFF_ENABLE 0.27285f
C1826 TERM_ENABLE HS_P_1 0.02404f
C1827 VCM_LOW_OK FS_N_OUT 0.1125f
C1828 HS_N_4 TERM_GATE_N_BLEED_1 0.0525f
C1829 PAD_N HS_P_7 0.3613f
C1830 HS_N_5 PULLUP_P_WELL 0.11805f
C1831 a_53878_132105# a_53878_131545# 0.0346f
C1832 TERM_VCM HS_N_7 0.16639f
C1833 PULLUP_P_BLEED_3 TERM_N_R 0.06105f
C1834 FS_P_OUT RX_N 0.00505f
C1835 TERM_OR_N_B PULLDOWN_P 0.04844f
C1836 TERM_VCM PULLUP_N_CONTROL_S 0.0423f
C1837 PULLUP_N_WELL PULLUP_N_BLEED_1 0.00587f
C1838 TERM_GATE_N HS_N_5 0.04924f
C1839 TERM_VCM FS_LOW_N 0.11348f
C1840 HS_N_7 TERM_ENABLE 0.10575f
C1841 PULLUP_N_BLEED_4 TERM_P_R 0.04588f
C1842 TERM_GATE_P_BLEED_0 HS_P_2 0.02483f
C1843 TERM_VCM FS_N_WELL 1.58767f
C1844 TERM_VCM TERM_OR_N_NS 0.03439f
C1845 HS_P FS_N_BLEED_6 0.11073f
C1846 TERM_ENABLE PULLUP_N_CONTROL_S 0.07644f
C1847 TERM_ENABLE FS_LOW_N 0.37409f
C1848 TERM_OR_P_B HS_P_0 0.09384f
C1849 HS_P_7 HS_P_13 0.14204f
C1850 HS_P HS_P_4 1.7567f
C1851 TERM_VCM PAD_P 0.0037f
C1852 HS_N_4 TERM_GATE_P 0.11218f
C1853 TERM_OR_N_S HS_N_8 0.03108f
C1854 FS_P_BLEED_2 PULLUP_P_GATE 0
C1855 TERM_ENABLE TERM_OR_N_NS 0.10081f
C1856 PULLUP_P VDD 2.22026f
C1857 TERM_ENABLE FS_N_WELL 2.50751f
C1858 HS_N TERM_GATE_N_BLEED_2 0.05048f
C1859 TERM_GATE_N_BLEED_1 PULLDOWN_N_R 0.07928f
C1860 HS_N_5 TERM_P_R 0.05893f
C1861 HS_N_11 FS_P_BLEED_2 0
C1862 HS_N_13 PAD_N 1.56314f
C1863 HS_N_7 PULLUP_P_BLEED_3 0.03489f
C1864 HS_N HS_PBIAS 0.39831f
C1865 HS_N_3 FS_P_OUT 0.48792f
C1866 HS_N_4 HS_N_6 0.05831f
C1867 DIV_N RX_P 0.72665f
C1868 PULLDOWN_P PULLUP_N_BLEED_0 0.06517f
C1869 TERM_N_R FS_N_OUT 0.38856f
C1870 PULLUP_P_BLEED_3 FS_LOW_N 0.00876f
C1871 TERM_GATE_P_BLEED_1 TERM_GATE_P_BLEED_2 1.09058f
C1872 FS_HIGH_P FS_HIGH_N 29.9593f
C1873 TERM_OR_P_S VDD 4.39982f
C1874 VCM_LOW_OK HS_PBIAS 0.42204f
C1875 VDD HS_N_9 5.99389f
C1876 HS_P_4 PULLUP_N_OUT 0.0863f
C1877 HS_N_13 HS_P_13 0.0245f
C1878 PULLDOWN_N_R TERM_GATE_P 0.26213f
C1879 TERM_OR_P_B TERM_P_R 0.76857f
C1880 HS_N_12 TERM_GATE_N_BLEED_2 0.02427f
C1881 VDD PULLUP_P_GATE 13.1722f
C1882 HS_N_11 VDD 6.59331f
C1883 FS_P_OUT PULLDOWN_P_R 0.73833f
C1884 FS_P_BLEED_1 FS_P_OUT 0
C1885 PULLUP_N_BLEED_2 PULLUP_N_BLEED_6 0.00257f
C1886 DIV_N HS_P 0.03732f
C1887 HS_N_5 HS_P_3 0.03089f
C1888 HS_N_12 HS_PBIAS 4.90809f
C1889 HS_N_6 PULLDOWN_N_R 0.06832f
C1890 DIV_ENABLE HS_N_10 0.03182f
C1891 HS_N PULLUP_N_BLEED_1 0.06387f
C1892 HS_N FS_N_GATE 2.07022f
C1893 HS_P TERM_OR_P_NS 0.04056f
C1894 FS_LOW_N FS_N_OUT 0.31306f
C1895 TERM_N_R TERM_GATE_N_BLEED_2 0.12212f
C1896 TERM_OR_P_B HS_P_3 0.10238f
C1897 TERM_VCM DIV_LOW_N 0.19527f
C1898 DIV_ENABLE FS_N_BLEED_4 0.03564f
C1899 PULLUP_P_BLEED_0 PULLUP_P_WELL 1.08596f
C1900 HS_N_0 HS_N_4 0.04165f
C1901 FS_N_WELL FS_N_OUT 0.1934p
C1902 HS_N_3 TERM_GATE_N_BLEED_0 0.03489f
C1903 TERM_VCM HS_N_1 0.12324f
C1904 PULLDOWN_N_R PULLUP_N_BLEED_6 0.04864f
C1905 TERM_OR_N_NS FS_N_OUT 0.06103f
C1906 HS_N PULLUP_P_BLEED_4 0.10264f
C1907 TERM_ENABLE PULLUP_P_BLEED_6 0
C1908 DIV_N PULLUP_N_OUT 0.04377f
C1909 TERM_N_R HS_PBIAS 0.70629f
C1910 TERM_GATE_N_BLEED_1 HS_N_8 0.0525f
C1911 HS_N_6 FS_P_WELL 1.97843f
C1912 HS_P_12 HS_P_2 0.00206f
C1913 TERM_ENABLE DIV_LOW_N 0.07174f
C1914 a_41005_132945# ESD_RAIL 0.53823f
C1915 PAD_P FS_N_OUT 0.17964f
C1916 TERM_ENABLE HS_N_1 0.04872f
C1917 FS_P_BLEED_4 PULLUP_P_WELL 0
C1918 FS_N_BLEED_3 FS_LOW_P 0.10387f
C1919 VCM_LOW_OK PULLUP_P_BLEED_4 0
C1920 PULLUP_N_OUT TERM_OR_P_NS 0.11021f
C1921 DIV_ENABLE FS_P_GATE 0.00424f
C1922 HS_P_1 HS_PBIAS 2.59892f
C1923 PULLUP_P_BLEED_3 PULLUP_P_BLEED_6 0
C1924 HS_N_12 FS_N_GATE 0.01973f
C1925 PULLUP_P_OUT TERM_GATE_P 0.40537f
C1926 FS_P_BLEED_2 FS_LOW_P 0.0781f
C1927 TERM_OR_P_B HS_P_8 0.10057f
C1928 HS_N_0 PULLDOWN_N_R 0.06832f
C1929 HS_N_7 TERM_GATE_N_BLEED_2 0.03702f
C1930 HS_N_8 TERM_GATE_P 0.12805f
C1931 HS_N_12 PULLUP_P_BLEED_4 0.05263f
C1932 HS_P_6 VDD 6.8233f
C1933 PULLUP_P_BLEED_3 HS_N_1 0.03489f
C1934 HS_N_7 HS_PBIAS 9.64698f
C1935 a_41005_133505# a_41005_134065# 0.0346f
C1936 HS_P_5 HS_P_11 0.03881f
C1937 HS_N_6 PULLUP_P_OUT 0.03489f
C1938 TERM_OR_N_B VDD 10.4444f
C1939 FS_LOW_N HS_PBIAS 0.39667f
C1940 TERM_N_R FS_N_GATE 0.76877f
C1941 HS_N_6 HS_N_8 0.04151f
C1942 TERM_VCM PULLUP_P 0.21883f
C1943 HS_N_2 VDD 5.27157f
C1944 PAD_N HS_P_4 0.27735f
C1945 TERM_OR_N_NS HS_PBIAS 0.04764f
C1946 HS_P_0 TERM_P_R 0.07626f
C1947 HS_N HS_N_5 4.65354f
C1948 FS_N_WELL HS_PBIAS 3.33611f
C1949 FS_HIGH_P FS_N_BLEED_2 0
C1950 VDD FS_LOW_P 3.59076f
C1951 DIV_P TERM_GATE_P 0.02274f
C1952 PULLUP_N_BLEED_3 PULLUP_P 0.05126f
C1953 PULLUP_P_WELL TERM_P_R 0.29295f
C1954 TERM_ENABLE PULLUP_P 0.04377f
C1955 HS_N_4 HS_P_10 0.07706f
C1956 PULLUP_P_CONTROL_S VDD 4.743f
C1957 HS_N_0 FS_P_WELL 2.61482f
C1958 HS_P FS_N_BLEED_0 0.09016f
C1959 VCM_LOW_OK HS_N_5 0.05893f
C1960 TERM_GATE_N TERM_P_R 0.1818f
C1961 DIV_LOW_N FS_N_OUT 0.11535f
C1962 TERM_VCM TERM_OR_P_S 0.05962f
C1963 TERM_GATE_P_BLEED_0 TERM_GATE_P_BLEED_2 0.10759f
C1964 HS_N_1 FS_N_OUT 0.06167f
C1965 TERM_VCM HS_N_9 0.14022f
C1966 VDD PULLUP_N_BLEED_0 0
C1967 HS_P_4 HS_P_13 0.14463f
C1968 TERM_GATE_P_BLEED_0 HS_P_11 0.03689f
C1969 HS_N TERM_OR_P_B 0.1311f
C1970 TERM_GATE_N_BLEED_0 PULLDOWN_P 0.04828f
C1971 HS_P PULLUP_N_OUT 0.09327f
C1972 TERM_ENABLE TERM_OR_P_S 0.23041f
C1973 TERM_VCM PULLUP_P_GATE 0.12603f
C1974 a_41005_132385# a_41005_131825# 0.0346f
C1975 PULLUP_P_BLEED_3 PULLUP_P 0.27184f
C1976 HS_N_12 HS_N_5 0
C1977 FS_N_BLEED_1 PULLDOWN_P 0.09712f
C1978 HS_P_9 TERM_GATE_P 0.22051f
C1979 TERM_ENABLE HS_N_9 0.04808f
C1980 TERM_OR_P_B VCM_LOW_OK 2.10826f
C1981 TERM_VCM HS_N_11 0.12019f
C1982 FS_N_BLEED_0 PULLUP_N_OUT 0
C1983 HS_P_0 HS_P_3 0.03772f
C1984 FS_LOW_N FS_N_GATE 0.75021f
C1985 HS_N_0 PULLUP_P_OUT 0.03489f
C1986 TERM_ENABLE PULLUP_P_GATE 0.84363f
C1987 HS_N_7 PULLUP_P_BLEED_4 0.0525f
C1988 FS_N_GATE FS_N_WELL 0.2903p
C1989 DIV_N PAD_N 0.68859f
C1990 PULLDOWN_N_R HS_P_10 0.07466f
C1991 PULLUP_N_BLEED_4 TERM_N_R 0.05729f
C1992 HS_N_11 TERM_ENABLE 0.04853f
C1993 HS_N_0 HS_N_8 0.04157f
C1994 DIV_ENABLE PULLUP_N_GATE 0
C1995 PULLUP_P_BLEED_4 FS_LOW_N 0.02437f
C1996 HS_N_5 TERM_N_R 0.05893f
C1997 PULLUP_P_BLEED_4 TERM_OR_N_NS 0
C1998 TERM_OR_P_B HS_N_12 0.07307f
C1999 FS_HIGH_P HS_N_10 0.02442f
C2000 PULLUP_P_BLEED_3 HS_N_9 0.03489f
C2001 FS_HIGH_P FS_N_BLEED_4 0.09418f
C2002 FS_P_BLEED_3 HS_N_10 0.02915f
C2003 PULLUP_P_BLEED_3 PULLUP_P_GATE 0.23044f
C2004 PULLUP_P_BLEED_6 HS_PBIAS 0.01633f
C2005 HS_P_5 HS_P_7 0.03078f
C2006 HS_N_1 TERM_GATE_N_BLEED_2 0.02451f
C2007 HS_P_3 TERM_P_R 0.12136f
C2008 DIV_LOW_N HS_PBIAS 0.09646f
C2009 HS_N_11 PULLUP_P_BLEED_3 0.03489f
C2010 FS_P_BLEED_2 FS_P_OUT 0
C2011 HS_N_0 DIV_P 0.03388f
C2012 HS_N_1 HS_PBIAS 2.51285f
C2013 PULLUP_P FS_N_OUT 0.52603f
C2014 HS_N_5 HS_P_1 0.03097f
C2015 HS_P_11 HS_N_10 0.00351f
C2016 PULLUP_N_WELL TERM_P_R 0.29516f
C2017 HS_N_10 FS_P_BLEED_0 0.06178f
C2018 TERM_OR_P_B TERM_N_R 1.12426f
C2019 TERM_OR_P_NS HS_P_13 0.02895f
C2020 FS_HIGH_P FS_P_GATE 5.63212f
C2021 PAD_N ESD_RAIL 22.6825f
C2022 HS_N_13 PULLUP_P_BLEED_5 0.02404f
C2023 PULLUP_N_BLEED_6 BYPASS_ENABLE 0.00766f
C2024 PAD_N RX_P 3.07596f
C2025 FS_P_BLEED_3 FS_P_GATE 0.27756f
C2026 HS_N_7 HS_N_5 0.07689f
C2027 FS_P_BLEED_5 FS_P_BLEED_3 0.12036f
C2028 HS_N_13 HS_P_5 0.03489f
C2029 HS_P_8 TERM_P_R 0.08296f
C2030 TERM_VCM HS_P_6 0.09619f
C2031 FS_LOW_N HS_N_5 0.08469f
C2032 PULLUP_P_OUT HS_P_10 0.05276f
C2033 TERM_OR_P_B HS_P_1 0.08191f
C2034 TERM_GATE_P_BLEED_0 HS_P_7 0.02404f
C2035 TERM_VCM TERM_OR_N_B 0.10825f
C2036 FS_P_OUT VDD 10.8417f
C2037 PULLUP_P_GATE FS_N_OUT 0.1125f
C2038 HS_N FS_P_BLEED_4 0.08043f
C2039 FS_HIGH_P FS_P_CONTROL_S 0.51548f
C2040 FS_P_BLEED_0 FS_P_GATE 0.16521f
C2041 HS_N_5 TERM_OR_N_NS 0.03425f
C2042 HS_P_12 HS_P_11 46.9655f
C2043 TERM_ENABLE HS_P_6 0.02404f
C2044 TERM_VCM HS_N_2 0.12019f
C2045 HS_N_8 HS_P_10 0.0286f
C2046 FS_P_BLEED_6 HS_N_10 0.06178f
C2047 HS_N HS_P_0 0.54906f
C2048 HS_N_3 HS_N_4 0.12319p
C2049 TERM_ENABLE TERM_OR_N_B 1.2192f
C2050 PULLUP_P TERM_GATE_N_BLEED_2 0.09196f
C2051 HS_N_5 PAD_P 0.34243f
C2052 HS_N PULLUP_P_WELL 0.29467f
C2053 TERM_ENABLE HS_N_2 0.04808f
C2054 TERM_VCM FS_LOW_P 0.24801f
C2055 FS_N_BLEED_1 FS_N_BLEED_3 0.10633f
C2056 HS_N_7 TERM_OR_P_B 0.07211f
C2057 PULLUP_N_BLEED_2 PULLUP_N_BLEED_5 0.00296f
C2058 HS_P PAD_N 1.82419f
C2059 FS_HIGH_N DIFF_ENABLE 0.2667f
C2060 PULLUP_P_BLEED_6 PULLUP_P_BLEED_4 0.00326f
C2061 PULLUP_N PULLUP_N_BLEED_2 0.29902f
C2062 PULLUP_P HS_PBIAS 0.35017f
C2063 VCM_LOW_OK HS_P_0 0.04122f
C2064 FS_P_CONTROL_S FS_P_BLEED_0 0.00276f
C2065 TERM_ENABLE PULLUP_P_CONTROL_S 0
C2066 HS_N TERM_GATE_N 0.08686f
C2067 TERM_ENABLE FS_LOW_P 0.13548f
C2068 PULLUP_P_BLEED_4 HS_N_1 0.05286f
C2069 FS_N_BLEED_5 FS_N_GATE 0.25656f
C2070 VCM_LOW_OK PULLUP_P_WELL 0.26131f
C2071 DIV_ENABLE TERM_GATE_N_BLEED_1 0
C2072 HS_P_3 HS_P_8 0.03109f
C2073 HS_N_4 PULLDOWN_P_R 0.02404f
C2074 HS_N_12 FS_P_BLEED_4 0.06178f
C2075 FS_P_BLEED_1 HS_N_4 0.03472f
C2076 TERM_GATE_N_BLEED_2 HS_N_9 0.04943f
C2077 FS_P_BLEED_6 FS_P_GATE 6.82321f
C2078 FS_P_BLEED_6 FS_P_BLEED_5 5.16949f
C2079 HS_P HS_P_13 0.71007f
C2080 HS_N_3 PULLDOWN_N_R 0.02404f
C2081 PULLUP_P_BLEED_3 HS_N_2 0.03489f
C2082 VCM_LOW_OK TERM_GATE_N 0.01725f
C2083 HS_N_12 HS_P_0 0.04378f
C2084 PAD_N PULLUP_N_OUT 1.29311f
C2085 HS_P_2 TERM_GATE_P 0.15718f
C2086 a_53878_132105# a_53878_132665# 0.0346f
C2087 HS_N TERM_P_R 0.11349f
C2088 HS_N_9 HS_PBIAS 1.96438f
C2089 HS_N_11 TERM_GATE_N_BLEED_2 0.02434f
C2090 PULLUP_N PULLDOWN_N_R 0.00106f
C2091 HS_N_12 PULLUP_P_WELL 0.12571f
C2092 TERM_GATE_N_BLEED_0 VDD 0.45815f
C2093 PULLUP_P_BLEED_3 FS_LOW_P 0.07139f
C2094 PULLUP_P_GATE HS_PBIAS 0.17404f
C2095 VCM_LOW_OK TERM_P_R 0.39366f
C2096 HS_P_9 HS_P_10 0.00887f
C2097 DIV_ENABLE TERM_GATE_P 0.00432f
C2098 HS_N_11 HS_PBIAS 2.65494f
C2099 FS_N_BLEED_1 VDD 0.00299f
C2100 HS_P_2 HS_N_6 0.03089f
C2101 TERM_GATE_N HS_N_12 0.04844f
C2102 HS_P_5 DIV_LOW_P 0.00305f
C2103 a_44789_117064# ESD_RAIL 13.9519f
C2104 FS_HIGH_P PULLUP_N_GATE 0.01763f
C2105 FS_N_GATE PULLUP_P 1.02581f
C2106 FS_P_BLEED_1 PULLDOWN_N_R 0.05445f
C2107 HS_P_6 FS_N_OUT 0.06167f
C2108 PULLUP_N_OUT HS_P_13 0.02868f
C2109 PULLDOWN_N_R PULLDOWN_P_R 33.296f
C2110 HS_N_3 FS_P_WELL 1.96364f
C2111 PULLUP_P_BLEED_6 HS_N_5 0
C2112 DIV_ENABLE HS_N_6 0.03089f
C2113 TERM_N_R PULLUP_P_WELL 0.33634f
C2114 PULLUP_P_BLEED_4 PULLUP_P 0.16921f
C2115 HS_N_12 TERM_P_R 0.0597f
C2116 DIV_LOW_N HS_N_5 0.06178f
C2117 HS_N_1 HS_N_5 0
C2118 HS_N HS_P_3 0.27803f
C2119 HS_P_12 HS_P_7 0.11376f
C2120 PULLUP_N_OUT PULLUP_P_BLEED_2 0
C2121 HS_P_0 HS_P_1 36.4065f
C2122 TERM_GATE_N TERM_N_R 26.1022f
C2123 HS_N_4 PULLDOWN_P 0.05303f
C2124 HS_N PULLUP_N_WELL 0.46804f
C2125 FS_N_GATE HS_N_9 0.01367f
C2126 HS_N_13 HS_N_10 0.09129f
C2127 FS_LOW_P FS_N_OUT 0.5386f
C2128 PULLUP_P_CONTROL_S FS_N_OUT 0.05082f
C2129 PULLDOWN_P_R FS_P_WELL 3.25452f
C2130 DIV_ENABLE PULLUP_N_BLEED_6 0.03269f
C2131 FS_P_BLEED_1 FS_P_WELL 0.02734f
C2132 PULLUP_N_BLEED_2 PULLDOWN_P 0.08014f
C2133 VCM_LOW_OK HS_P_3 0.09096f
C2134 HS_N_7 FS_P_BLEED_4 0.06246f
C2135 DIV_P RX_N 0.37599f
C2136 HS_N_3 PULLUP_P_OUT 0.03489f
C2137 PULLUP_N_GATE PULLDOWN_N 0.00151f
C2138 TERM_N_R TERM_P_R 28.0337f
C2139 PULLUP_P_BLEED_4 HS_N_9 0.0525f
C2140 HS_N_11 FS_N_GATE 0.00893f
C2141 TERM_OR_P_B HS_N_1 0.07438f
C2142 HS_N_7 HS_P_0 0
C2143 HS_P_5 HS_P_4 32.9896f
C2144 HS_N_3 HS_N_8 0.03258f
C2145 HS_N HS_P_8 0.19016f
C2146 PULLUP_P_BLEED_4 PULLUP_P_GATE 0.10639f
C2147 HS_N_7 PULLUP_P_WELL 0.12519f
C2148 HS_N_12 HS_P_3 0.02482f
C2149 PULLUP_N_BLEED_4 PULLUP_P 0.10721f
C2150 TERM_VCM FS_P_OUT 0.38638f
C2151 HS_N_13 HS_P_12 0.03621f
C2152 HS_N_13 FS_P_GATE 1.03609f
C2153 HS_N_11 PULLUP_P_BLEED_4 0.05266f
C2154 HS_N_7 TERM_GATE_N 0.05007f
C2155 HS_P_6 HS_PBIAS 2.09103f
C2156 HS_N_13 FS_P_BLEED_5 0.06178f
C2157 HS_N_2 TERM_GATE_N_BLEED_2 0.02404f
C2158 PULLDOWN_P PULLDOWN_N_R 88.8288f
C2159 VCM_LOW_OK HS_P_8 0.03489f
C2160 HS_P_1 TERM_P_R 0.10249f
C2161 HS_P_0 PAD_P 1.64024f
C2162 TERM_ENABLE FS_P_OUT 0.53051f
C2163 FS_P_BLEED_1 PULLUP_P_OUT 0.05902f
C2164 TERM_OR_N_B HS_PBIAS 0.01781f
C2165 PULLUP_P_OUT PULLDOWN_P_R 0.13835f
C2166 DIV_ENABLE HS_N_0 2.34864f
C2167 HS_N_5 PULLUP_P 0.0678f
C2168 TERM_GATE_N FS_LOW_N 0.09048f
C2169 HS_N_2 HS_PBIAS 1.31428f
C2170 FS_P_BLEED_1 HS_N_8 0.03472f
C2171 HS_N_3 DIV_P 0.03388f
C2172 HS_N_8 PULLDOWN_P_R 0.02404f
C2173 HS_N_13 FS_P_CONTROL_S 0.03226f
C2174 HS_N_7 TERM_P_R 0.10033f
C2175 TERM_N_R HS_P_3 0.05037f
C2176 PULLUP_N_CONTROL_S TERM_P_R 0.0414f
C2177 PULLUP_P_CONTROL_S HS_PBIAS 0.07486f
C2178 FS_LOW_P HS_PBIAS 0.34356f
C2179 FS_LOW_N TERM_P_R 0.03634f
C2180 TERM_GATE_P_BLEED_0 HS_P_4 0.02451f
C2181 a_53878_132105# ESD_RAIL 0.53942f
C2182 RX_N BYPASS_ENABLE 7.32117f
C2183 TERM_N_R PULLUP_N_WELL 0.3392f
C2184 FS_HIGH_P TERM_GATE_N_BLEED_1 0.01347f
C2185 TERM_P_R FS_N_WELL 1.29698f
C2186 TERM_OR_N_NS TERM_P_R 0.21356f
C2187 DIV_N HS_P_5 0.01203f
C2188 HS_N_5 HS_N_9 0.04079f
C2189 DIV_LOW_P HS_N_10 0.00259f
C2190 HS_P_3 HS_P_1 0.06154f
C2191 TERM_P_R PAD_P 0.63614f
C2192 PAD_N HS_P_13 0.16938f
C2193 PULLUP_N_BLEED_0 HS_PBIAS 0.07928f
C2194 HS_N_5 PULLUP_P_GATE 0.08413f
C2195 a_53878_134345# a_53878_133785# 0.0346f
C2196 HS_P FS_HIGH_N 0.03743f
C2197 TERM_VCM TERM_GATE_N_BLEED_0 0.04263f
C2198 HS_P_5 TERM_OR_P_NS 0.02846f
C2199 HS_N_11 HS_N_5 0
C2200 TERM_GATE_P_BLEED_1 PULLUP_N_OUT 0.05318f
C2201 HS_N VCM_LOW_OK 0.07865f
C2202 TERM_OR_P_B TERM_OR_P_S 1.83456f
C2203 FS_HIGH_N FS_N_BLEED_0 0.32903f
C2204 TERM_ENABLE TERM_GATE_N_BLEED_0 0.04931f
C2205 TERM_OR_P_B HS_N_9 0.07254f
C2206 HS_P_2 HS_P_10 0
C2207 TERM_ENABLE FS_N_BLEED_1 0.01168f
C2208 FS_P_BLEED_4 HS_N_1 0.06178f
C2209 FS_N_GATE FS_LOW_P 0.45819f
C2210 HS_P_8 HS_P_1 0.02404f
C2211 PULLDOWN_P_R HS_P_9 0.07466f
C2212 PULLUP_N_CONTROL_S PULLUP_N_WELL 0.11761f
C2213 HS_N_11 TERM_OR_P_B 0.07338f
C2214 a_43813_117064# a_42245_90628# 0.00994f
C2215 HS_N_2 PULLUP_P_BLEED_4 0.0525f
C2216 FS_LOW_N PULLUP_N_WELL 0.20869f
C2217 FS_P_OUT FS_N_OUT 1.00178f
C2218 HS_N_1 HS_P_0 0.04113f
C2219 HS_N HS_N_12 8.83112f
C2220 FS_HIGH_P HS_N_6 0.02404f
C2221 FS_HIGH_N PULLUP_N_OUT 0.04377f
C2222 TERM_GATE_P_BLEED_2 TERM_GATE_P 0.40344f
C2223 HS_P_3 PAD_P 1.68578f
C2224 HS_N_6 FS_P_BLEED_3 0.03529f
C2225 HS_N_1 PULLUP_P_WELL 0.1499f
C2226 HS_P_11 TERM_GATE_P 0.1736f
C2227 PULLUP_P_BLEED_4 FS_LOW_P 0.0781f
C2228 PULLUP_N_BLEED_1 PULLUP_N_BLEED_0 3.40429f
C2229 VCM_LOW_OK HS_N_12 0.05893f
C2230 DIV_LOW_N TERM_GATE_N 0.06956f
C2231 FS_N_BLEED_3 PULLDOWN_N_R 0.08856f
C2232 FS_P_BLEED_1 BYPASS_ENABLE 0.00766f
C2233 TERM_GATE_N HS_N_1 0.05139f
C2234 HS_P PULLUP_P_BLEED_5 0.10446f
C2235 ESD_RAIL a_41005_131825# 0.53823f
C2236 HS_N_13 TERM_OR_N_S 0.02464f
C2237 HS_N_6 HS_P_11 0.03089f
C2238 FS_HIGH_P PULLUP_N_BLEED_6 0.08992f
C2239 HS_N_6 FS_P_BLEED_0 0.06178f
C2240 HS_N TERM_N_R 0.14159f
C2241 HS_N_4 VDD 6.4024f
C2242 PULLUP_P PULLUP_P_BLEED_0 0.82084f
C2243 DIV_LOW_N TERM_P_R 0.0414f
C2244 HS_P HS_P_5 5.05127f
C2245 HS_P_6 HS_N_5 0.05828f
C2246 HS_N_1 TERM_P_R 0.06087f
C2247 HS_P_4 HS_P_12 0
C2248 HS_P_8 PAD_P 1.09993f
C2249 VCM_LOW_OK TERM_N_R 0.18442f
C2250 HS_N HS_P_1 0.75007f
C2251 HS_N_2 HS_N_5 0.00106f
C2252 PULLUP_N_OUT PULLUP_P_BLEED_5 0.09196f
C2253 TERM_GATE_N_BLEED_0 FS_N_OUT 0.06167f
C2254 FS_P_OUT HS_PBIAS 0.96844f
C2255 FS_HIGH_P HS_N_0 0.02438f
C2256 FS_P_BLEED_2 FS_P_WELL 0.00213f
C2257 DIV_N HS_N_10 0.03462f
C2258 PULLDOWN_N_R VDD 2.95843f
C2259 PULLDOWN_N PULLUP_N_BLEED_6 0
C2260 FS_P_BLEED_6 HS_N_6 0.06178f
C2261 VCM_LOW_OK HS_P_1 0.03489f
C2262 PULLUP_P PULLUP_P_WELL 0.15487f
C2263 HS_N_12 TERM_N_R 0.0597f
C2264 PULLUP_P_BLEED_0 PULLUP_P_GATE 0.16374f
C2265 TERM_OR_P_B HS_P_6 0.10133f
C2266 HS_N_5 PULLUP_P_CONTROL_S 0.04808f
C2267 HS_N_7 HS_N 0.69419f
C2268 HS_N_0 FS_P_BLEED_3 0.02973f
C2269 HS_N_5 FS_LOW_P 0.08533f
C2270 HS_P_5 PULLUP_N_OUT 0.02859f
C2271 DIV_ENABLE RX_N 0.7437f
C2272 FS_P_BLEED_4 HS_N_9 0.06295f
C2273 TERM_GATE_N PULLUP_P 0.21883f
C2274 HS_N FS_LOW_N 0.11362f
C2275 HS_P TERM_GATE_P_BLEED_0 0.00154f
C2276 TERM_OR_P_B HS_N_2 0.07258f
C2277 HS_N_1 HS_P_3 0.02599f
C2278 HS_P FS_N_BLEED_2 0.08856f
C2279 HS_P_0 HS_N_9 0.03791f
C2280 HS_N FS_N_WELL 4.96692f
C2281 HS_N_7 VCM_LOW_OK 0.05893f
C2282 FS_P_BLEED_4 PULLUP_P_GATE 0
C2283 HS_N TERM_OR_N_NS 0.04764f
C2284 HS_N_11 FS_P_BLEED_4 0.06178f
C2285 HS_N_0 FS_P_BLEED_0 0.06178f
C2286 FS_N_BLEED_0 FS_N_BLEED_2 0.12309f
C2287 DIV_N HS_P_12 0.01246f
C2288 DIV_N FS_P_GATE 0.09711f
C2289 VCM_LOW_OK FS_LOW_N 0.22524f
C2290 PULLUP_P_WELL HS_N_9 0.14182f
C2291 FS_P_BLEED_2 PULLUP_P_OUT 0.00257f
C2292 TERM_OR_P_B FS_LOW_P 1.1369f
C2293 FS_P_WELL VDD 99.794f
C2294 HS_N PAD_P 1.23865f
C2295 PULLUP_P TERM_P_R 0.1121f
C2296 HS_P_7 TERM_GATE_P 0.15508f
C2297 PULLUP_P_WELL PULLUP_P_GATE 35.6995f
C2298 VCM_LOW_OK TERM_OR_N_NS 7.88232f
C2299 HS_N_11 HS_P_0 0.04389f
C2300 TERM_GATE_N_BLEED_0 TERM_GATE_N_BLEED_2 0.00153f
C2301 TERM_GATE_N HS_N_9 0.05172f
C2302 HS_N_11 PULLUP_P_WELL 0.13224f
C2303 HS_P_12 TERM_OR_P_NS 0.03931f
C2304 HS_N_7 HS_N_12 0.02955f
C2305 PULLUP_N_GATE DIFF_ENABLE 0.07144f
C2306 HS_N_13 TERM_GATE_N_BLEED_1 0.0525f
C2307 FS_N_BLEED_5 PULLUP_N_WELL 0
C2308 VCM_LOW_OK PAD_P 0.00567f
C2309 TERM_GATE_N_BLEED_0 HS_PBIAS 0.04828f
C2310 TERM_GATE_P_BLEED_0 PULLUP_N_OUT 0.10679f
C2311 DIV_ENABLE HS_N_3 0.03089f
C2312 PULLUP_N_OUT FS_N_BLEED_2 0.10124f
C2313 HS_N_12 FS_LOW_N 0.08441f
C2314 TERM_OR_P_S TERM_P_R 2.01371f
C2315 HS_N_11 TERM_GATE_N 0.04856f
C2316 FS_N_BLEED_1 HS_PBIAS 0.08856f
C2317 HS_N_12 FS_N_WELL 0.00912f
C2318 HS_N_0 FS_P_BLEED_6 0.06178f
C2319 HS_N_9 TERM_P_R 0.0592f
C2320 HS_N_12 TERM_OR_N_NS 0.03425f
C2321 HS_P_2 PULLDOWN_P_R 0.07466f
C2322 PULLUP_N_GATE FS_N_BLEED_6 0
C2323 HS_N_12 PAD_P 2.18792f
C2324 PULLUP_P_GATE TERM_P_R 0.15811f
C2325 HS_N_7 TERM_N_R 0.11615f
C2326 PULLUP_P_OUT VDD 3.24314f
C2327 HS_N_13 TERM_GATE_P 0.1076f
C2328 HS_N_11 TERM_P_R 0.05996f
C2329 DIV_ENABLE FS_P_BLEED_1 0.01375f
C2330 TERM_N_R PULLUP_N_CONTROL_S 0.05859f
C2331 HS_N_8 VDD 4.98108f
C2332 FS_LOW_N TERM_N_R 0.11177f
C2333 HS_P HS_N_10 0.25322f
C2334 PULLUP_P PULLUP_N_WELL 9.02284f
C2335 TERM_N_R TERM_OR_N_NS 0.04867f
C2336 TERM_N_R FS_N_WELL 1.45715f
C2337 HS_N_13 HS_N_6 0.08101f
C2338 HS_P_11 HS_P_10 48.3384f
C2339 HS_P FS_N_BLEED_4 0.04811f
C2340 HS_N_7 HS_P_1 0
C2341 TERM_VCM HS_N_4 0.12411f
C2342 TERM_N_R PAD_P 0.19266f
C2343 HS_N DIV_LOW_N 0.08856f
C2344 FS_N_BLEED_0 FS_N_BLEED_4 0.00763f
C2345 HS_P_3 HS_N_9 0.03089f
C2346 DIV_P VDD 0.11168f
C2347 HS_P_6 HS_P_0 0.04603f
C2348 TERM_ENABLE HS_N_4 0.04808f
C2349 HS_N HS_N_1 4.22798f
C2350 FS_N_BLEED_1 FS_N_GATE 0.29846f
C2351 PULLUP_P_BLEED_0 PULLUP_P_CONTROL_S 0.00275f
C2352 HS_P HS_P_12 3.63983f
C2353 PULLUP_N_BLEED_2 PULLUP_N_BLEED_3 0.39425f
C2354 HS_P FS_P_GATE 1.05827f
C2355 HS_P_5 PAD_N 1.55482f
C2356 VCM_LOW_OK PULLUP_P_BLEED_6 0
C2357 HS_N_2 FS_P_BLEED_4 0.06178f
C2358 FS_P_OUT HS_N_5 0.43331f
C2359 HS_N_11 HS_P_3 0.02508f
C2360 HS_P_1 PAD_P 1.23389f
C2361 HS_P FS_P_BLEED_5 0.06178f
C2362 HS_N_7 FS_LOW_N 0.08486f
C2363 FS_N_BLEED_4 PULLUP_N_OUT 0.05445f
C2364 HS_N_2 HS_P_0 0.03722f
C2365 VCM_LOW_OK HS_N_1 0.05893f
C2366 HS_N FS_N_BLEED_5 0.02443f
C2367 HS_N_7 TERM_OR_N_NS 0.03425f
C2368 HS_N_2 PULLUP_P_WELL 0.11473f
C2369 TERM_VCM PULLDOWN_N_R 0.28542f
C2370 PULLUP_P_BLEED_3 HS_N_4 0.03489f
C2371 TERM_GATE_N TERM_OR_N_B 1.45686f
C2372 HS_P_0 FS_LOW_P 0.0932f
C2373 HS_P_8 HS_N_9 0.10431f
C2374 HS_N_7 PAD_P 0.03829f
C2375 FS_LOW_N FS_N_WELL 0.90409f
C2376 HS_P FS_P_CONTROL_S 0.03246f
C2377 ESD_RAIL a_53878_133785# 0.53942f
C2378 FS_LOW_N TERM_OR_N_NS 3.61751f
C2379 DIV_ENABLE PULLDOWN_P 0.04428f
C2380 TERM_GATE_N HS_N_2 0.04808f
C2381 PULLUP_P_WELL FS_LOW_P 0.27223f
C2382 PULLUP_N_BLEED_3 PULLDOWN_N_R 0.00237f
C2383 PULLDOWN_P FS_N_CONTROL_S 0.09439f
C2384 DIV_LOW_N HS_N_12 0.06178f
C2385 HS_P_9 VDD 6.02581f
C2386 PULLUP_P_CONTROL_S PULLUP_P_WELL 0.02696f
C2387 HS_P_5 HS_P_13 0.26928f
C2388 HS_P_12 PULLUP_N_OUT 0.03006f
C2389 HS_N_12 HS_N_1 0.03364f
C2390 HS_P_6 TERM_P_R 0.08356f
C2391 PULLUP_N_OUT FS_P_GATE 1.30807f
C2392 TERM_OR_P_B FS_P_OUT 0.16122f
C2393 TERM_ENABLE PULLDOWN_N_R 0.07871f
C2394 FS_P_BLEED_5 PULLUP_N_OUT 0.05922f
C2395 HS_N_13 HS_N_0 0.07993f
C2396 DIV_LOW_P TERM_GATE_P 0.00428f
C2397 TERM_GATE_N FS_LOW_P 0.04939f
C2398 TERM_OR_N_B TERM_P_R 0.37734f
C2399 a_41005_132385# a_41005_131545# 0
C2400 VDD BYPASS_ENABLE 0.03959f
C2401 HS_N_2 TERM_P_R 0.0594f
C2402 TERM_VCM FS_P_WELL 1.40942f
C2403 HS_N PULLUP_P 0.03743f
C2404 ESD_RAIL a_41005_134065# 0.57348f
C2405 DIV_LOW_N TERM_N_R 0.14472f
C2406 FS_LOW_P TERM_P_R 0.15007f
C2407 PULLUP_P_BLEED_3 PULLDOWN_N_R 0.05462f
C2408 HS_N_1 TERM_N_R 0.06392f
C2409 TERM_GATE_N_BLEED_0 HS_N_5 0.03489f
C2410 TERM_ENABLE FS_P_WELL 2.50111f
C2411 VCM_LOW_OK PULLUP_P 0.08753f
C2412 TERM_GATE_P_BLEED_0 HS_P_13 0.0256f
C2413 FS_HIGH_P HS_N_3 0.02404f
C2414 HS_P_10 HS_P_7 0.10683f
C2415 HS_P_6 HS_P_3 0.07261f
C2416 HS_N_3 FS_P_BLEED_3 0.03144f
C2417 HS_N HS_N_9 5.97147f
C2418 HS_N_1 HS_P_1 0.09066f
C2419 HS_N PULLUP_P_GATE 0.13616f
C2420 TERM_VCM PULLUP_P_OUT 0.36501f
C2421 HS_N_7 PULLUP_P_BLEED_6 0
C2422 VCM_LOW_OK TERM_OR_P_S 1.87902f
C2423 HS_N_2 HS_P_3 0.02451f
C2424 HS_N_12 PULLUP_P 0.0678f
C2425 HS_P_4 TERM_GATE_P 0.15627f
C2426 VCM_LOW_OK HS_N_9 0.05893f
C2427 HS_N_11 HS_N 5.51295f
C2428 TERM_VCM HS_N_8 0.13427f
C2429 PULLUP_P_BLEED_6 FS_LOW_N 0.02395f
C2430 TERM_ENABLE PULLUP_P_OUT 11.6132f
C2431 HS_P PULLUP_N_GATE 0.11746f
C2432 HS_N_7 DIV_LOW_N 0.06178f
C2433 HS_N_3 FS_P_BLEED_0 0.06178f
C2434 FS_HIGH_P FS_P_BLEED_1 0.16649f
C2435 DIFF_ENABLE PULLUP_N_BLEED_6 0.35616f
C2436 HS_N_7 HS_N_1 0.03096f
C2437 HS_P_3 FS_LOW_P 0.04607f
C2438 FS_HIGH_P PULLDOWN_P_R 0.04377f
C2439 PULLUP_P_BLEED_6 TERM_OR_N_NS 0
C2440 PAD_N HS_N_10 1.35483f
C2441 PULLDOWN_N_R FS_N_OUT 0.56245f
C2442 VCM_LOW_OK PULLUP_P_GATE 0.22296f
C2443 DIV_LOW_N FS_LOW_N 0.06178f
C2444 DIV_N TERM_GATE_N_BLEED_1 0
C2445 HS_N_1 FS_LOW_N 0.12614f
C2446 HS_P_4 HS_N_6 0.03738f
C2447 TERM_ENABLE HS_N_8 0.04808f
C2448 HS_N_11 VCM_LOW_OK 0.05893f
C2449 HS_P_6 HS_P_8 0.00206f
C2450 HS_N_0 DIV_LOW_P 0.00585f
C2451 PULLUP_N_WELL FS_LOW_P 0.28858f
C2452 HS_P TERM_OR_N_S 0.05632f
C2453 HS_N_1 TERM_OR_N_NS 0.03425f
C2454 HS_N_4 TERM_GATE_N_BLEED_2 0.02921f
C2455 TERM_N_R PULLUP_P 0.34532f
C2456 HS_N_12 HS_N_9 0.02504f
C2457 PULLUP_N PULLDOWN_N 0
C2458 HS_N_12 PULLUP_P_GATE 0.08333f
C2459 HS_N_4 HS_PBIAS 2.61651f
C2460 TERM_VCM DIV_P 0.13218f
C2461 HS_N_1 PAD_P 0.48214f
C2462 FS_P_BLEED_1 FS_P_BLEED_0 8.76361f
C2463 HS_P_11 PULLDOWN_P_R 0.07466f
C2464 PULLUP_N_GATE PULLUP_N_OUT 16.6062f
C2465 PULLDOWN_P_R FS_P_BLEED_0 0.10124f
C2466 FS_N_BLEED_5 FS_LOW_N 0.084f
C2467 FS_P_OUT HS_P_0 0.09146f
C2468 PULLUP_N_BLEED_2 HS_PBIAS 0.01633f
C2469 HS_N_10 HS_P_13 0.0252f
C2470 HS_P_8 FS_LOW_P 0.04566f
C2471 PULLUP_N_WELL PULLUP_N_BLEED_0 5.00789f
C2472 HS_N_11 HS_N_12 0.1373p
C2473 DIV_ENABLE FS_P_BLEED_2 0
C2474 PULLUP_P_BLEED_3 HS_N_8 0.03489f
C2475 FS_P_WELL FS_N_OUT 0.93211f
C2476 HS_N_3 FS_P_BLEED_6 0.06178f
C2477 PAD_N HS_P_12 0.22324f
C2478 DIV_N TERM_GATE_P 0.00178f
C2479 TERM_N_R TERM_OR_P_S 0.0546f
C2480 TERM_OR_N_S PULLUP_N_OUT 0.13603f
C2481 TERM_N_R HS_N_9 0.0592f
C2482 PULLDOWN_N_R TERM_GATE_N_BLEED_2 0.07928f
C2483 TERM_N_R PULLUP_P_GATE 0.16992f
C2484 TERM_VCM HS_P_9 0.1405f
C2485 HS_N_7 PULLUP_P 0.07466f
C2486 DIV_N HS_N_6 0.03462f
C2487 HS_P_2 VDD 5.70329f
C2488 HS_N_11 TERM_N_R 0.05996f
C2489 PULLUP_N_CONTROL_S PULLUP_P 0.09193f
C2490 HS_P_12 HS_P_13 47.0352f
C2491 HS_P_13 FS_P_GATE 0.19446f
C2492 FS_P_BLEED_6 PULLDOWN_P_R 0.10124f
C2493 HS_N HS_P_6 0.5265f
C2494 PULLDOWN_N_R HS_PBIAS 0.82033f
C2495 TERM_ENABLE HS_P_9 0.07435f
C2496 HS_N_9 HS_P_1 0.0312f
C2497 FS_LOW_N PULLUP_P 0.06432f
C2498 PULLUP_P_OUT FS_N_OUT 0.06167f
C2499 FS_P_OUT TERM_P_R 0.43231f
C2500 VDD FS_N_CONTROL_S 3.02358f
C2501 PULLUP_P FS_N_WELL 1.91861f
C2502 DIV_ENABLE VDD 0.3424f
C2503 HS_N_6 TERM_OR_P_NS 0.00351f
C2504 PULLUP_P TERM_OR_N_NS 0.05397f
C2505 TERM_VCM BYPASS_ENABLE 0.00889f
C2506 HS_N HS_N_2 6.83901f
C2507 HS_P_6 VCM_LOW_OK 0.03489f
C2508 HS_N_8 FS_N_OUT 0.06167f
C2509 PULLUP_N_BLEED_2 PULLUP_N_BLEED_1 1.89414f
C2510 HS_N_7 HS_N_9 0.04397f
C2511 VCM_LOW_OK TERM_OR_N_B 2.86687f
C2512 TERM_GATE_P_BLEED_1 TERM_GATE_P_BLEED_0 2.63577f
C2513 HS_N FS_LOW_P 0.10015f
C2514 PULLUP_P_BLEED_4 HS_N_4 0.0525f
C2515 HS_N PULLUP_P_CONTROL_S 0.11565f
C2516 HS_N_7 PULLUP_P_GATE 0.08496f
C2517 VCM_LOW_OK HS_N_2 0.05893f
C2518 HS_P TERM_GATE_N_BLEED_1 0.0525f
C2519 FS_LOW_N HS_N_9 0.08512f
C2520 FS_P_WELL HS_PBIAS 3.47125f
C2521 HS_N_7 HS_N_11 0.02985f
C2522 DIV_LOW_N HS_N_1 0.06178f
C2523 HS_P_6 HS_N_12 0.05906f
C2524 TERM_OR_N_NS HS_N_9 0.03425f
C2525 HS_N_9 FS_N_WELL 0.00889f
C2526 PULLDOWN_P PULLDOWN_N 2.04789f
C2527 VCM_LOW_OK FS_LOW_P 0.34798f
C2528 HS_N_11 FS_LOW_N 0.08441f
C2529 TERM_GATE_N TERM_GATE_N_BLEED_0 4.39906f
C2530 HS_N PULLUP_N_BLEED_0 0.12943f
C2531 DIV_P FS_N_OUT 2.20134f
C2532 PULLDOWN_N_R PULLUP_N_BLEED_1 0.07928f
C2533 FS_P_OUT HS_P_3 0.09146f
C2534 FS_N_GATE PULLDOWN_N_R 1.16382f
C2535 HS_N_9 PAD_P 1.20851f
C2536 FS_HIGH_N FS_N_BLEED_2 0.00429f
C2537 HS_N_11 TERM_OR_N_NS 0.03425f
C2538 DIV_N HS_N_0 0.03952f
C2539 HS_N_11 FS_N_WELL 0.00889f
C2540 HS_N_2 HS_N_12 0.02585f
C2541 PULLDOWN_P_R HS_P_7 0.02411f
C2542 PULLUP_P_BLEED_3 BYPASS_ENABLE 0.00766f
C2543 TERM_GATE_N_BLEED_1 PULLUP_N_OUT 0.09196f
C2544 HS_P TERM_GATE_P 0.22621f
C2545 HS_N_13 HS_N_3 0.279f
C2546 HS_N_11 PAD_P 0.38848f
C2547 PULLUP_P_BLEED_4 PULLDOWN_N_R 0.09196f
C2548 HS_N_12 FS_LOW_P 0.08505f
C2549 HS_N_8 TERM_GATE_N_BLEED_2 0.04243f
C2550 HS_N_12 PULLUP_P_CONTROL_S 0.04885f
C2551 PULLUP_P_OUT HS_PBIAS 0.55061f
C2552 TERM_GATE_N_BLEED_0 TERM_P_R 0.04766f
C2553 HS_P_4 HS_P_10 0
C2554 TERM_OR_N_B TERM_N_R 5.91987f
C2555 HS_N_8 HS_PBIAS 3.45151f
C2556 PULLUP_N_BLEED_2 PULLUP_N_BLEED_4 0.00234f
C2557 HS_P HS_N_6 1.04391f
C2558 HS_N_2 TERM_N_R 0.0594f
C2559 PULLUP_P_BLEED_6 PULLUP_P 0.14694f
C2560 HS_P_6 HS_P_1 0.06271f
C2561 HS_N_4 HS_N_5 0.12253p
C2562 DIV_LOW_N PULLUP_P 0.10124f
C2563 HS_N_13 PULLDOWN_P_R 0.02404f
C2564 PULLUP_N_OUT TERM_GATE_P 0.37427f
C2565 HS_N_1 PULLUP_P 0.02404f
C2566 HS_N_13 FS_P_BLEED_1 0.03472f
C2567 TERM_N_R FS_LOW_P 0.16749f
C2568 FS_HIGH_P FS_N_BLEED_3 0
C2569 HS_N_2 HS_P_1 0.09798f
C2570 HS_P PULLUP_N_BLEED_6 0.04828f
C2571 HS_N_7 HS_P_6 0.02536f
C2572 PULLUP_N_BLEED_4 PULLDOWN_N_R 0
C2573 ATB_ESD_RAIL VSS 0.86326f
C2574 RX_N VSS 44.4745f
C2575 RX_P VSS 43.7342f
C2576 BYPASS_ENABLE VSS 60.3857f
C2577 HS_N VSS 56.645f
C2578 HS_P VSS 40.6501f
C2579 PAD_P VSS 0.37048p
C2580 PAD_N VSS 0.36624p
C2581 FS_LOW_P VSS 38.0085f
C2582 TERM_ENABLE VSS 51.3239f
C2583 DIV_ENABLE VSS 22.9277f
C2584 TERM_VCM VSS 0.11353p
C2585 HS_PBIAS VSS 49.4032f
C2586 FS_HIGH_P VSS 8.62107f
C2587 PULLUP_P VSS 19.459f
C2588 PULLDOWN_P VSS 14.2957f
C2589 FS_LOW_N VSS 8.47881f
C2590 FS_HIGH_N VSS 4.29973f
C2591 PULLUP_N VSS 3.12827f
C2592 DIFF_ENABLE VSS 21.3621f
C2593 PULLDOWN_N VSS 4.99637f
C2594 ESD_RAIL VSS 1841.015664f
C2595 VDD VSS 0.72412p
C2596 m2_42279_124800# VSS 7.46506f $ **FLOATING
C2597 a_42245_90628# VSS 0.24984p
C2598 a_44789_117064# VSS 12.0947f
C2599 a_43813_117064# VSS 5.60447f
C2600 TERM_OR_P_S VSS 3.53275f
C2601 TERM_OR_P_NS VSS 10.064f
C2602 a_41005_131545# VSS 0.10822p
C2603 a_53878_131545# VSS 0.07835f
C2604 a_41005_131825# VSS 0.07377f
C2605 a_53878_132105# VSS 0.07394f
C2606 a_41005_132385# VSS 0.07377f
C2607 a_53878_132665# VSS 0.07394f
C2608 a_41005_132945# VSS 0.07377f
C2609 a_53878_133225# VSS 0.07394f
C2610 a_41005_133505# VSS 0.07377f
C2611 a_53878_133785# VSS 0.07394f
C2612 a_41005_134065# VSS 0.07377f
C2613 TERM_GATE_P_BLEED_2 VSS 3.28565f
C2614 TERM_GATE_P_BLEED_1 VSS 5.10072f
C2615 TERM_GATE_P_BLEED_0 VSS 7.68181f
C2616 TERM_OR_P_B VSS 21.1533f
C2617 a_53878_134345# VSS 0.07838f
C2618 TERM_GATE_P VSS 27.0289f
C2619 HS_P_4 VSS 7.08828f
C2620 HS_P_3 VSS 7.10742f
C2621 HS_P_2 VSS 6.92881f
C2622 HS_P_1 VSS 5.64833f
C2623 HS_P_0 VSS 7.04643f
C2624 DIV_LOW_P VSS 7.23693f
C2625 DIV_P VSS 14.1199f
C2626 HS_P_11 VSS 8.66739f
C2627 HS_P_10 VSS 6.56271f
C2628 HS_P_9 VSS 7.07186f
C2629 HS_P_8 VSS 5.68784f
C2630 HS_P_7 VSS 4.83585f
C2631 HS_P_6 VSS 5.96193f
C2632 HS_P_5 VSS 7.82827f
C2633 HS_P_13 VSS 6.1434f
C2634 HS_P_12 VSS 7.62117f
C2635 a_41684_148611# VSS 0.28621p
C2636 a_41684_160275# VSS 1.50941p
C2637 FS_P_BLEED_0 VSS 5.25478f
C2638 FS_P_CONTROL_S VSS 4.50476f
C2639 FS_P_OUT VSS 33.2921f
C2640 FS_P_GATE VSS 50.584f
C2641 FS_P_BLEED_6 VSS 4.71981f
C2642 FS_P_BLEED_5 VSS 4.09514f
C2643 FS_P_BLEED_4 VSS 3.52334f
C2644 FS_P_BLEED_3 VSS 3.16733f
C2645 FS_P_BLEED_2 VSS 3.71625f
C2646 FS_P_BLEED_1 VSS 8.07846f
C2647 PULLUP_P_OUT VSS 22.0369f
C2648 PULLUP_P_BLEED_2 VSS 4.21729f
C2649 PULLUP_P_BLEED_1 VSS 3.22052f
C2650 PULLUP_P_BLEED_0 VSS 3.1427f
C2651 PULLUP_P_CONTROL_S VSS 14.2222f
C2652 PULLDOWN_P_R VSS 21.8133f
C2653 PULLUP_P_GATE VSS 18.622f
C2654 PULLUP_P_BLEED_6 VSS 5.9721f
C2655 PULLUP_P_BLEED_5 VSS 8.83533f
C2656 PULLUP_P_BLEED_4 VSS 11.7853f
C2657 PULLUP_P_BLEED_3 VSS 8.31118f
C2658 TERM_OR_N_B VSS 9.20695f
C2659 TERM_OR_N_S VSS 8.30319f
C2660 TERM_OR_N_NS VSS 5.94472f
C2661 VCM_LOW_OK VSS 25.8357f
C2662 TERM_GATE_N_BLEED_2 VSS 14.3664f
C2663 TERM_GATE_N_BLEED_1 VSS 13.4026f
C2664 TERM_GATE_N_BLEED_0 VSS 8.30278f
C2665 HS_N_0 VSS 11.8194f
C2666 DIV_LOW_N VSS 8.79168f
C2667 DIV_N VSS 18.8798f
C2668 TERM_GATE_N VSS 18.495f
C2669 HS_N_7 VSS 9.28359f
C2670 HS_N_6 VSS 9.29898f
C2671 HS_N_5 VSS 8.48041f
C2672 HS_N_4 VSS 7.55183f
C2673 HS_N_3 VSS 7.91514f
C2674 HS_N_2 VSS 8.95462f
C2675 HS_N_1 VSS 9.59159f
C2676 HS_N_13 VSS 9.06212f
C2677 HS_N_12 VSS 9.99856f
C2678 HS_N_11 VSS 9.36849f
C2679 HS_N_10 VSS 9.03359f
C2680 HS_N_9 VSS 8.5391f
C2681 HS_N_8 VSS 9.00333f
C2682 FS_N_CONTROL_S VSS 6.67541f
C2683 FS_N_OUT VSS 66.0491f
C2684 FS_N_BLEED_3 VSS 5.83837f
C2685 FS_N_BLEED_2 VSS 4.75153f
C2686 FS_N_BLEED_1 VSS 4.13355f
C2687 FS_N_BLEED_0 VSS 3.57892f
C2688 FS_N_GATE VSS 51.2723f
C2689 FS_N_BLEED_6 VSS 3.35184f
C2690 FS_N_BLEED_5 VSS 3.45768f
C2691 FS_N_BLEED_4 VSS 8.08501f
C2692 PULLUP_N_CONTROL_S VSS 4.4075f
C2693 PULLUP_N_OUT VSS 44.4704f
C2694 PULLUP_N_BLEED_5 VSS 4.51663f
C2695 PULLUP_N_BLEED_4 VSS 3.53996f
C2696 PULLUP_N_BLEED_3 VSS 2.95235f
C2697 PULLUP_N_BLEED_2 VSS 3.88779f
C2698 PULLUP_N_BLEED_1 VSS 6.69252f
C2699 PULLUP_N_BLEED_0 VSS 9.62445f
C2700 TERM_P_R VSS 90.06779f
C2701 TERM_N_R VSS 0.10882p
C2702 PULLDOWN_N_R VSS 36.5261f
C2703 PULLUP_N_GATE VSS 18.208f
C2704 PULLUP_N_BLEED_6 VSS 8.22239f
C2705 FS_P_WELL VSS 0.43173p
C2706 PULLUP_P_WELL VSS 97.9489f
C2707 FS_N_WELL VSS 0.43826p
C2708 PULLUP_N_WELL VSS 0.10052p
DWELL_ARRAY VSS ESD_RAIL diode_nw2ps_06v0 area=569.4528p pj=470.72u
.ends

.lib /home/ubuntu/svalbard/scratch/transceiver-pad-pdk/ngspice/sm141064.ngspice diode_typical
.lib /home/ubuntu/svalbard/scratch/transceiver-pad-pdk/ngspice/sm141064.ngspice mimcap_typical
