.subckt tx_protected_pad PAD_P PAD_N VDD VSS CASCODE MAIN_P MAIN_N MAIN_BIAS POST_P POST_N POST_BIAS TMDS_P TMDS_N TMDS_BIAS DETECT_ENABLE DETECT_PBIAS TERM_ENABLE TERM_VCM ATB_ESD_RAIL
XPHYSICAL PAD_P PAD_N VDD VSS CASCODE MAIN_P MAIN_N MAIN_BIAS POST_P POST_N POST_BIAS TMDS_P TMDS_N TMDS_BIAS DETECT_ENABLE DETECT_PBIAS TERM_ENABLE TERM_VCM ESD_RAIL ATB_ESD_RAIL combined_flat
.ends tx_protected_pad
* NGSPICE file created from combined_flat.ext - technology: gf180mcuD

.subckt combined_flat PAD_P PAD_N VDD VSS CASCODE MAIN_P MAIN_N MAIN_BIAS POST_P POST_N
+ POST_BIAS TMDS_P TMDS_N TMDS_BIAS DETECT_ENABLE DETECT_PBIAS TERM_ENABLE TERM_VCM
+ ESD_RAIL ATB_ESD_RAIL
X0 ESD_RAIL a_34245_90628# VSS VSS nfet_06v0 ad=13p pd=50.52u as=13p ps=50.52u w=50u l=0.7u
X1 a_33684_148611# a_33684_148611# a_33684_160275# VSS nfet_06v0 ad=13p pd=50.52u as=13p ps=50.52u w=50u l=0.7u
X2 TERM_BLEED_6 VSS VSS ppolyf_u_1k r_width=1u r_length=12.5u
X3 a_33684_160275# a_33684_160275# VSS VSS nfet_06v0 ad=13p pd=50.52u as=13p ps=50.52u w=50u l=0.7u
X4 a_33684_148611# a_33684_148611# a_33684_160275# VSS nfet_06v0 ad=13p pd=50.52u as=13p ps=50.52u w=50u l=0.7u
X5 POST_TAIL_6 POST_BIAS VSS VSS nfet_03v3 ad=8.8p pd=40.88u as=8.8p ps=40.88u w=20u l=1u
X6 a_33684_148611# ESD_RAIL ESD_RAIL VSS nfet_06v0 ad=13p pd=50.52u as=13p ps=50.52u w=50u l=0.7u
X7 VSS a_33684_160275# a_33684_160275# VSS nfet_06v0 ad=13p pd=50.52u as=13p ps=50.52u w=50u l=0.7u
X8 ESD_RAIL VSS cap_mim_2f0_m4m5_noshield c_width=31.6u c_length=31.6u
X9 a_33684_160275# a_33684_148611# a_33684_148611# VSS nfet_06v0 ad=13p pd=50.52u as=13p ps=50.52u w=50u l=0.7u
X10 a_33684_148611# a_33684_148611# a_33684_160275# VSS nfet_06v0 ad=13p pd=50.52u as=13p ps=50.52u w=50u l=0.7u
X11 POST_TAIL_4 POST_BIAS VSS VSS nfet_03v3 ad=8.8p pd=40.88u as=8.8p ps=40.88u w=20u l=1u
X12 a_33684_160275# a_33684_148611# a_33684_148611# VSS nfet_06v0 ad=13p pd=50.52u as=13p ps=50.52u w=50u l=0.7u
X13 ESD_RAIL ESD_RAIL a_33684_148611# VSS nfet_06v0 ad=13p pd=50.52u as=13p ps=50.52u w=50u l=0.7u
X14 SUM_N_D_6 POST_N POST_TAIL_6 VSS nfet_03v3 ad=8.8p pd=40.88u as=8.8p ps=40.88u w=20u l=0.28u
X15 a_33684_160275# a_33684_148611# a_33684_148611# VSS nfet_06v0 ad=13p pd=50.52u as=13p ps=50.52u w=50u l=0.7u
X16 a_33684_148611# a_33684_148611# a_33684_160275# VSS nfet_06v0 ad=13p pd=50.52u as=13p ps=50.52u w=50u l=0.7u
X17 VSS a_33684_160275# a_33684_160275# VSS nfet_06v0 ad=13p pd=50.52u as=13p ps=50.52u w=50u l=0.7u
X18 a_33684_160275# a_33684_148611# a_33684_148611# VSS nfet_06v0 ad=13p pd=50.52u as=13p ps=50.52u w=50u l=0.7u
X19 a_33684_160275# a_33684_160275# VSS VSS nfet_06v0 ad=13p pd=50.52u as=13p ps=50.52u w=50u l=0.7u
X20 a_33684_160275# a_33684_148611# a_33684_148611# VSS nfet_06v0 ad=13p pd=50.52u as=13p ps=50.52u w=50u l=0.7u
X21 a_33684_160275# a_33684_148611# a_33684_148611# VSS nfet_06v0 ad=13p pd=50.52u as=13p ps=50.52u w=50u l=0.7u
X22 a_33684_148611# a_33684_148611# a_33684_160275# VSS nfet_06v0 ad=13p pd=50.52u as=13p ps=50.52u w=50u l=0.7u
X23 a_33684_160275# a_33684_148611# a_33684_148611# VSS nfet_06v0 ad=13p pd=50.52u as=13p ps=50.52u w=50u l=0.7u
X24 VSS a_34245_90628# ESD_RAIL VSS nfet_06v0 ad=13p pd=50.52u as=13p ps=50.52u w=50u l=0.7u
X25 VSS a_34245_90628# ESD_RAIL VSS nfet_06v0 ad=13p pd=50.52u as=13p ps=50.52u w=50u l=0.7u
X26 TERM_P_R TERM_ENABLE_LOCAL TERM_VCM VSS nfet_03v3 ad=8.8p pd=40.88u as=8.8p ps=40.88u w=20u l=0.28u
X27 TMDS_TAIL_5 TMDS_BIAS VSS VSS nfet_03v3 ad=8.8p pd=40.88u as=8.8p ps=40.88u w=20u l=1u
X28 VSS a_33684_160275# a_33684_160275# VSS nfet_06v0 ad=13p pd=50.52u as=13p ps=50.52u w=50u l=0.7u
X29 TERM_BLEED_0 TERM_BLEED_1 VSS ppolyf_u_1k r_width=1u r_length=12.5u
X30 MAIN_TAIL_1 MAIN_BIAS VSS VSS nfet_03v3 ad=8.8p pd=40.88u as=8.8p ps=40.88u w=20u l=1u
X31 SUM_N_D_4 POST_N POST_TAIL_4 VSS nfet_03v3 ad=8.8p pd=40.88u as=8.8p ps=40.88u w=20u l=0.28u
X32 VSS a_33684_160275# a_33684_160275# VSS nfet_06v0 ad=13p pd=50.52u as=13p ps=50.52u w=50u l=0.7u
X33 a_33684_160275# a_33684_160275# VSS VSS nfet_06v0 ad=13p pd=50.52u as=13p ps=50.52u w=50u l=0.7u
X34 VSS a_33684_160275# a_33684_160275# VSS nfet_06v0 ad=13p pd=50.52u as=13p ps=50.52u w=50u l=0.7u
X35 VSS a_33684_160275# a_33684_160275# VSS nfet_06v0 ad=13p pd=50.52u as=13p ps=50.52u w=50u l=0.7u
X36 a_33684_148611# a_33684_148611# a_33684_160275# VSS nfet_06v0 ad=13p pd=50.52u as=13p ps=50.52u w=50u l=0.7u
X37 TERM_N_R TERM_ENABLE_LOCAL TERM_VCM VSS nfet_03v3 ad=8.8p pd=40.88u as=8.8p ps=40.88u w=20u l=0.28u
X38 POST_TAIL_6 POST_BIAS VSS VSS nfet_03v3 ad=8.8p pd=40.88u as=8.8p ps=40.88u w=20u l=1u
X39 a_33684_160275# a_33684_148611# a_33684_148611# VSS nfet_06v0 ad=13p pd=50.52u as=13p ps=50.52u w=50u l=0.7u
X40 SUM_N_D_4 MAIN_N MAIN_TAIL_4 VSS nfet_03v3 ad=8.8p pd=40.88u as=8.8p ps=40.88u w=20u l=0.28u
X41 a_33684_160275# a_33684_160275# VSS VSS nfet_06v0 ad=13p pd=50.52u as=13p ps=50.52u w=50u l=0.7u
X42 ESD_RAIL ESD_RAIL a_33684_148611# VSS nfet_06v0 ad=13p pd=50.52u as=13p ps=50.52u w=50u l=0.7u
X43 TERM_BLEED_2 TERM_BLEED_3 VSS ppolyf_u_1k r_width=1u r_length=12.5u
X44 VSS a_33684_160275# a_33684_160275# VSS nfet_06v0 ad=13p pd=50.52u as=13p ps=50.52u w=50u l=0.7u
X45 a_33684_148611# ESD_RAIL ESD_RAIL VSS nfet_06v0 ad=13p pd=50.52u as=13p ps=50.52u w=50u l=0.7u
X46 ESD_RAIL a_34245_90628# VSS VSS nfet_06v0 ad=13p pd=50.52u as=13p ps=50.52u w=50u l=0.7u
X47 VSS a_33684_160275# a_33684_160275# VSS nfet_06v0 ad=13p pd=50.52u as=13p ps=50.52u w=50u l=0.7u
X48 VSS a_34245_90628# ESD_RAIL VSS nfet_06v0 ad=13p pd=50.52u as=13p ps=50.52u w=50u l=0.7u
X49 VSS a_33684_160275# a_33684_160275# VSS nfet_06v0 ad=13p pd=50.52u as=13p ps=50.52u w=50u l=0.7u
X50 a_33684_160275# a_33684_160275# VSS VSS nfet_06v0 ad=13p pd=50.52u as=13p ps=50.52u w=50u l=0.7u
X51 VSS a_33684_160275# a_33684_160275# VSS nfet_06v0 ad=13p pd=50.52u as=13p ps=50.52u w=50u l=0.7u
D0 VSS PAD_P diode_nd2ps_06v0 pj=51.8u area=22.5p
X52 a_33684_160275# a_33684_160275# VSS VSS nfet_06v0 ad=13p pd=50.52u as=13p ps=50.52u w=50u l=0.7u
X53 TMDS_TAIL_3 TMDS_BIAS VSS VSS nfet_03v3 ad=8.8p pd=40.88u as=8.8p ps=40.88u w=20u l=1u
X54 a_33684_160275# a_33684_148611# a_33684_148611# VSS nfet_06v0 ad=13p pd=50.52u as=13p ps=50.52u w=50u l=0.7u
X55 VSS a_33684_160275# a_33684_160275# VSS nfet_06v0 ad=13p pd=50.52u as=13p ps=50.52u w=50u l=0.7u
X56 VSS a_33684_160275# a_33684_160275# VSS nfet_06v0 ad=13p pd=50.52u as=13p ps=50.52u w=50u l=0.7u
X57 a_33684_148611# a_33684_148611# a_33684_160275# VSS nfet_06v0 ad=13p pd=50.52u as=13p ps=50.52u w=50u l=0.7u
X58 DETECT_BLEED_4 DETECT_BLEED_5 VSS ppolyf_u_1k r_width=1u r_length=12.5u
X59 a_33684_160275# a_33684_160275# VSS VSS nfet_06v0 ad=13p pd=50.52u as=13p ps=50.52u w=50u l=0.7u
X60 MAIN_TAIL_4 MAIN_BIAS VSS VSS nfet_03v3 ad=8.8p pd=40.88u as=8.8p ps=40.88u w=20u l=1u
X61 a_33684_148611# ESD_RAIL ESD_RAIL VSS nfet_06v0 ad=13p pd=50.52u as=13p ps=50.52u w=50u l=0.7u
X62 a_33684_160275# a_33684_160275# VSS VSS nfet_06v0 ad=13p pd=50.52u as=13p ps=50.52u w=50u l=0.7u
X63 ESD_RAIL ESD_RAIL a_33684_148611# VSS nfet_06v0 ad=13p pd=50.52u as=13p ps=50.52u w=50u l=0.7u
X64 SUM_N_D_2 MAIN_N MAIN_TAIL_2 VSS nfet_03v3 ad=8.8p pd=40.88u as=8.8p ps=40.88u w=20u l=0.28u
X65 VSS a_33684_160275# a_33684_160275# VSS nfet_06v0 ad=13p pd=50.52u as=13p ps=50.52u w=50u l=0.7u
X66 VSS a_33684_160275# a_33684_160275# VSS nfet_06v0 ad=13p pd=50.52u as=13p ps=50.52u w=50u l=0.7u
X67 ESD_RAIL a_34245_90628# VSS VSS nfet_06v0 ad=13p pd=50.52u as=13p ps=50.52u w=50u l=0.7u
X68 a_33684_160275# a_33684_160275# VSS VSS nfet_06v0 ad=13p pd=50.52u as=13p ps=50.52u w=50u l=0.7u
X69 ESD_RAIL a_34245_90628# VSS VSS nfet_06v0 ad=13p pd=50.52u as=13p ps=50.52u w=50u l=0.7u
D1 VSS ESD_RAIL diode_nd2ps_06v0 pj=82u area=40p
X70 a_36789_117064# a_35813_117064# VSS VSS nfet_06v0 ad=1.3p pd=5.52u as=2.2p ps=10.88u w=5u l=0.7u
X71 a_33684_148611# ESD_RAIL ESD_RAIL VSS nfet_06v0 ad=13p pd=50.52u as=13p ps=50.52u w=50u l=0.7u
X72 TERM_P_R TERM_ENABLE_LOCAL TERM_VCM VSS nfet_03v3 ad=8.8p pd=40.88u as=8.8p ps=40.88u w=20u l=0.28u
X73 a_33684_160275# a_33684_160275# VSS VSS nfet_06v0 ad=13p pd=50.52u as=13p ps=50.52u w=50u l=0.7u
X74 VSS a_33684_160275# a_33684_160275# VSS nfet_06v0 ad=13p pd=50.52u as=13p ps=50.52u w=50u l=0.7u
X75 MAIN_TAIL_7 MAIN_BIAS VSS VSS nfet_03v3 ad=8.8p pd=40.88u as=8.8p ps=40.88u w=20u l=1u
X76 a_33684_148611# ESD_RAIL ESD_RAIL VSS nfet_06v0 ad=13p pd=50.52u as=13p ps=50.52u w=50u l=0.7u
X77 DETECT_P_I DETECT_ENABLE_LOCAL PAD_P VSS nfet_06v0 ad=1.76p pd=8.88u as=1.76p ps=8.88u w=4u l=0.7u
D2 VSS ESD_RAIL diode_nd2ps_06v0 pj=82u area=40p
X78 ESD_RAIL ESD_RAIL a_33684_148611# VSS nfet_06v0 ad=13p pd=50.52u as=13p ps=50.52u w=50u l=0.7u
X79 VSS a_33684_160275# a_33684_160275# VSS nfet_06v0 ad=13p pd=50.52u as=13p ps=50.52u w=50u l=0.7u
X80 a_33684_148611# ESD_RAIL ESD_RAIL VSS nfet_06v0 ad=13p pd=50.52u as=13p ps=50.52u w=50u l=0.7u
X81 a_33684_148611# ESD_RAIL ESD_RAIL VSS nfet_06v0 ad=13p pd=50.52u as=13p ps=50.52u w=50u l=0.7u
X82 a_33684_160275# a_33684_160275# VSS VSS nfet_06v0 ad=13p pd=50.52u as=13p ps=50.52u w=50u l=0.7u
X83 a_33684_160275# a_33684_160275# VSS VSS nfet_06v0 ad=13p pd=50.52u as=13p ps=50.52u w=50u l=0.7u
X84 VSS a_33684_160275# a_33684_160275# VSS nfet_06v0 ad=13p pd=50.52u as=13p ps=50.52u w=50u l=0.7u
X85 a_33684_148611# ESD_RAIL ESD_RAIL VSS nfet_06v0 ad=13p pd=50.52u as=13p ps=50.52u w=50u l=0.7u
X86 ESD_RAIL ESD_RAIL a_33684_148611# VSS nfet_06v0 ad=13p pd=50.52u as=13p ps=50.52u w=50u l=0.7u
X87 VSS a_33684_160275# a_33684_160275# VSS nfet_06v0 ad=13p pd=50.52u as=13p ps=50.52u w=50u l=0.7u
X88 SUM_N_D_7 MAIN_N MAIN_TAIL_7 VSS nfet_03v3 ad=8.8p pd=40.88u as=8.8p ps=40.88u w=20u l=0.28u
X89 a_33684_148611# ESD_RAIL ESD_RAIL VSS nfet_06v0 ad=13p pd=50.52u as=13p ps=50.52u w=50u l=0.7u
X90 a_33684_160275# a_33684_160275# VSS VSS nfet_06v0 ad=13p pd=50.52u as=13p ps=50.52u w=50u l=0.7u
X91 VSS a_33684_160275# a_33684_160275# VSS nfet_06v0 ad=13p pd=50.52u as=13p ps=50.52u w=50u l=0.7u
X92 a_33684_148611# ESD_RAIL ESD_RAIL VSS nfet_06v0 ad=13p pd=50.52u as=13p ps=50.52u w=50u l=0.7u
X93 a_33684_160275# a_33684_160275# VSS VSS nfet_06v0 ad=13p pd=50.52u as=13p ps=50.52u w=50u l=0.7u
X94 ESD_RAIL ESD_RAIL a_33684_148611# VSS nfet_06v0 ad=13p pd=50.52u as=13p ps=50.52u w=50u l=0.7u
X95 a_33684_148611# ESD_RAIL ESD_RAIL VSS nfet_06v0 ad=13p pd=50.52u as=13p ps=50.52u w=50u l=0.7u
X96 a_33684_148611# a_33684_148611# a_33684_160275# VSS nfet_06v0 ad=13p pd=50.52u as=13p ps=50.52u w=50u l=0.7u
X97 ESD_RAIL ESD_RAIL a_33684_148611# VSS nfet_06v0 ad=13p pd=50.52u as=13p ps=50.52u w=50u l=0.7u
X98 a_33684_160275# a_33684_148611# a_33684_148611# VSS nfet_06v0 ad=13p pd=50.52u as=13p ps=50.52u w=50u l=0.7u
X99 TMDS_TAIL_2 TMDS_BIAS VSS VSS nfet_03v3 ad=8.8p pd=40.88u as=8.8p ps=40.88u w=20u l=1u
X100 VSS a_33684_160275# a_33684_160275# VSS nfet_06v0 ad=13p pd=50.52u as=13p ps=50.52u w=50u l=0.7u
X101 a_33684_148611# ESD_RAIL ESD_RAIL VSS nfet_06v0 ad=13p pd=50.52u as=13p ps=50.52u w=50u l=0.7u
X102 a_33684_148611# ESD_RAIL ESD_RAIL VSS nfet_06v0 ad=13p pd=50.52u as=13p ps=50.52u w=50u l=0.7u
X103 a_33684_160275# a_33684_160275# VSS VSS nfet_06v0 ad=13p pd=50.52u as=13p ps=50.52u w=50u l=0.7u
X104 ESD_RAIL ESD_RAIL a_33684_148611# VSS nfet_06v0 ad=13p pd=50.52u as=13p ps=50.52u w=50u l=0.7u
X105 a_33684_160275# a_33684_160275# VSS VSS nfet_06v0 ad=13p pd=50.52u as=13p ps=50.52u w=50u l=0.7u
X106 a_33005_131825# a_45878_131545# ESD_RAIL ppolyf_u r_width=0.8u r_length=63.855u
X107 ESD_RAIL ESD_RAIL a_33684_148611# VSS nfet_06v0 ad=13p pd=50.52u as=13p ps=50.52u w=50u l=0.7u
X108 DETECT_BLEED_0 DETECT_BLEED_1 VSS ppolyf_u_1k r_width=1u r_length=12.5u
X109 POST_TAIL_1 POST_BIAS VSS VSS nfet_03v3 ad=8.8p pd=40.88u as=8.8p ps=40.88u w=20u l=1u
X110 a_33684_148611# ESD_RAIL ESD_RAIL VSS nfet_06v0 ad=13p pd=50.52u as=13p ps=50.52u w=50u l=0.7u
X111 VSS a_33684_160275# a_33684_160275# VSS nfet_06v0 ad=13p pd=50.52u as=13p ps=50.52u w=50u l=0.7u
X112 a_33684_148611# ESD_RAIL ESD_RAIL VSS nfet_06v0 ad=13p pd=50.52u as=13p ps=50.52u w=50u l=0.7u
X113 a_33684_160275# a_33684_160275# VSS VSS nfet_06v0 ad=13p pd=50.52u as=13p ps=50.52u w=50u l=0.7u
X114 SUM_N_D_0 POST_N POST_TAIL_0 VSS nfet_03v3 ad=8.8p pd=40.88u as=8.8p ps=40.88u w=20u l=0.28u
X115 ESD_RAIL ESD_RAIL a_33684_148611# VSS nfet_06v0 ad=13p pd=50.52u as=13p ps=50.52u w=50u l=0.7u
X116 a_33684_160275# a_33684_148611# a_33684_148611# VSS nfet_06v0 ad=13p pd=50.52u as=13p ps=50.52u w=50u l=0.7u
X117 MAIN_TAIL_7 MAIN_BIAS VSS VSS nfet_03v3 ad=8.8p pd=40.88u as=8.8p ps=40.88u w=20u l=1u
X118 a_33684_160275# a_33684_160275# VSS VSS nfet_06v0 ad=13p pd=50.52u as=13p ps=50.52u w=50u l=0.7u
X119 a_33684_148611# a_33684_148611# a_33684_160275# VSS nfet_06v0 ad=13p pd=50.52u as=13p ps=50.52u w=50u l=0.7u
X120 VSS a_34245_90628# ESD_RAIL VSS nfet_06v0 ad=13p pd=50.52u as=13p ps=50.52u w=50u l=0.7u
X121 ESD_RAIL ESD_RAIL a_33684_148611# VSS nfet_06v0 ad=13p pd=50.52u as=13p ps=50.52u w=50u l=0.7u
X122 VSS a_33684_160275# a_33684_160275# VSS nfet_06v0 ad=13p pd=50.52u as=13p ps=50.52u w=50u l=0.7u
X123 a_33684_148611# ESD_RAIL ESD_RAIL VSS nfet_06v0 ad=13p pd=50.52u as=13p ps=50.52u w=50u l=0.7u
X124 POST_TAIL_5 POST_BIAS VSS VSS nfet_03v3 ad=8.8p pd=40.88u as=8.8p ps=40.88u w=20u l=1u
X125 a_33684_148611# ESD_RAIL ESD_RAIL VSS nfet_06v0 ad=13p pd=50.52u as=13p ps=50.52u w=50u l=0.7u
X126 a_33684_160275# a_33684_160275# VSS VSS nfet_06v0 ad=13p pd=50.52u as=13p ps=50.52u w=50u l=0.7u
X127 ESD_RAIL ESD_RAIL a_33684_148611# VSS nfet_06v0 ad=13p pd=50.52u as=13p ps=50.52u w=50u l=0.7u
D3 VSS PAD_P diode_nd2ps_06v0 pj=51.8u area=22.5p
X128 ESD_RAIL ESD_RAIL a_33684_148611# VSS nfet_06v0 ad=13p pd=50.52u as=13p ps=50.52u w=50u l=0.7u
X129 VSS a_33684_160275# a_33684_160275# VSS nfet_06v0 ad=13p pd=50.52u as=13p ps=50.52u w=50u l=0.7u
X130 a_33684_148611# ESD_RAIL ESD_RAIL VSS nfet_06v0 ad=13p pd=50.52u as=13p ps=50.52u w=50u l=0.7u
X131 a_33684_148611# ESD_RAIL ESD_RAIL VSS nfet_06v0 ad=13p pd=50.52u as=13p ps=50.52u w=50u l=0.7u
X132 ESD_RAIL ESD_RAIL a_33684_148611# VSS nfet_06v0 ad=13p pd=50.52u as=13p ps=50.52u w=50u l=0.7u
X133 a_33684_160275# a_33684_160275# VSS VSS nfet_06v0 ad=13p pd=50.52u as=13p ps=50.52u w=50u l=0.7u
X134 VSS a_33684_160275# a_33684_160275# VSS nfet_06v0 ad=13p pd=50.52u as=13p ps=50.52u w=50u l=0.7u
X135 a_33684_160275# a_33684_148611# a_33684_148611# VSS nfet_06v0 ad=13p pd=50.52u as=13p ps=50.52u w=50u l=0.7u
X136 a_33684_148611# ESD_RAIL ESD_RAIL VSS nfet_06v0 ad=13p pd=50.52u as=13p ps=50.52u w=50u l=0.7u
X137 VSS a_33684_160275# a_33684_160275# VSS nfet_06v0 ad=13p pd=50.52u as=13p ps=50.52u w=50u l=0.7u
X138 MAIN_TAIL_5 MAIN_BIAS VSS VSS nfet_03v3 ad=8.8p pd=40.88u as=8.8p ps=40.88u w=20u l=1u
X139 ESD_RAIL ESD_RAIL a_33684_148611# VSS nfet_06v0 ad=13p pd=50.52u as=13p ps=50.52u w=50u l=0.7u
X140 a_33684_148611# a_33684_148611# a_33684_160275# VSS nfet_06v0 ad=13p pd=50.52u as=13p ps=50.52u w=50u l=0.7u
X141 VSS a_34245_90628# ESD_RAIL VSS nfet_06v0 ad=13p pd=50.52u as=13p ps=50.52u w=50u l=0.7u
X142 SUM_P_D_7 TMDS_P TMDS_TAIL_7 VSS nfet_03v3 ad=8.8p pd=40.88u as=8.8p ps=40.88u w=20u l=0.28u
X143 a_33684_160275# a_33684_148611# a_33684_148611# VSS nfet_06v0 ad=13p pd=50.52u as=13p ps=50.52u w=50u l=0.7u
X144 PAD_P CASCODE SUM_P_D_4 VSS nfet_06v0 ad=7.04p pd=32.88u as=7.04p ps=32.88u w=16u l=0.7u
X145 VSS a_33684_160275# a_33684_160275# VSS nfet_06v0 ad=13p pd=50.52u as=13p ps=50.52u w=50u l=0.7u
X146 a_33684_148611# ESD_RAIL ESD_RAIL VSS nfet_06v0 ad=13p pd=50.52u as=13p ps=50.52u w=50u l=0.7u
X147 ESD_RAIL ESD_RAIL a_33684_148611# VSS nfet_06v0 ad=13p pd=50.52u as=13p ps=50.52u w=50u l=0.7u
X148 a_33684_148611# a_33684_148611# a_33684_160275# VSS nfet_06v0 ad=13p pd=50.52u as=13p ps=50.52u w=50u l=0.7u
X149 ESD_RAIL ESD_RAIL a_33684_148611# VSS nfet_06v0 ad=13p pd=50.52u as=13p ps=50.52u w=50u l=0.7u
X150 a_33684_148611# ESD_RAIL ESD_RAIL VSS nfet_06v0 ad=13p pd=50.52u as=13p ps=50.52u w=50u l=0.7u
X151 VSS a_33684_160275# a_33684_160275# VSS nfet_06v0 ad=13p pd=50.52u as=13p ps=50.52u w=50u l=0.7u
X152 ESD_RAIL a_34245_90628# VSS VSS nfet_06v0 ad=13p pd=50.52u as=13p ps=50.52u w=50u l=0.7u
X153 a_33005_132945# a_45878_132665# ESD_RAIL ppolyf_u r_width=0.8u r_length=63.855u
X154 ESD_RAIL ESD_RAIL a_33684_148611# VSS nfet_06v0 ad=13p pd=50.52u as=13p ps=50.52u w=50u l=0.7u
X155 POST_TAIL_4 POST_BIAS VSS VSS nfet_03v3 ad=8.8p pd=40.88u as=8.8p ps=40.88u w=20u l=1u
X156 a_33684_148611# a_33684_148611# a_33684_160275# VSS nfet_06v0 ad=13p pd=50.52u as=13p ps=50.52u w=50u l=0.7u
X157 a_33684_160275# a_33684_148611# a_33684_148611# VSS nfet_06v0 ad=13p pd=50.52u as=13p ps=50.52u w=50u l=0.7u
X158 ESD_RAIL a_34245_90628# VSS VSS nfet_06v0 ad=13p pd=50.52u as=13p ps=50.52u w=50u l=0.7u
X159 ESD_RAIL ESD_RAIL a_33684_148611# VSS nfet_06v0 ad=13p pd=50.52u as=13p ps=50.52u w=50u l=0.7u
X160 POST_TAIL_7 POST_BIAS VSS VSS nfet_03v3 ad=8.8p pd=40.88u as=8.8p ps=40.88u w=20u l=1u
X161 a_33684_160275# a_33684_148611# a_33684_148611# VSS nfet_06v0 ad=13p pd=50.52u as=13p ps=50.52u w=50u l=0.7u
X162 SUM_N_D_5 MAIN_N MAIN_TAIL_5 VSS nfet_03v3 ad=8.8p pd=40.88u as=8.8p ps=40.88u w=20u l=0.28u
X163 a_33684_148611# ESD_RAIL ESD_RAIL VSS nfet_06v0 ad=13p pd=50.52u as=13p ps=50.52u w=50u l=0.7u
X164 a_33684_148611# a_33684_148611# a_33684_160275# VSS nfet_06v0 ad=13p pd=50.52u as=13p ps=50.52u w=50u l=0.7u
X165 a_33684_148611# a_33684_148611# a_33684_160275# VSS nfet_06v0 ad=13p pd=50.52u as=13p ps=50.52u w=50u l=0.7u
X166 SUM_P_D_5 TMDS_P TMDS_TAIL_5 VSS nfet_03v3 ad=8.8p pd=40.88u as=8.8p ps=40.88u w=20u l=0.28u
X167 ESD_RAIL ESD_RAIL a_33684_148611# VSS nfet_06v0 ad=13p pd=50.52u as=13p ps=50.52u w=50u l=0.7u
X168 a_33684_160275# a_33684_160275# VSS VSS nfet_06v0 ad=13p pd=50.52u as=13p ps=50.52u w=50u l=0.7u
X169 a_33684_148611# ESD_RAIL ESD_RAIL VSS nfet_06v0 ad=13p pd=50.52u as=13p ps=50.52u w=50u l=0.7u
X170 VSS a_34245_90628# ESD_RAIL VSS nfet_06v0 ad=13p pd=50.52u as=13p ps=50.52u w=50u l=0.7u
X171 a_33684_160275# a_33684_148611# a_33684_148611# VSS nfet_06v0 ad=13p pd=50.52u as=13p ps=50.52u w=50u l=0.7u
X172 VSS a_33684_160275# a_33684_160275# VSS nfet_06v0 ad=13p pd=50.52u as=13p ps=50.52u w=50u l=0.7u
X173 ESD_RAIL ESD_RAIL a_33684_148611# VSS nfet_06v0 ad=13p pd=50.52u as=13p ps=50.52u w=50u l=0.7u
X174 a_33684_148611# ESD_RAIL ESD_RAIL VSS nfet_06v0 ad=13p pd=50.52u as=13p ps=50.52u w=50u l=0.7u
X175 a_33684_160275# a_33684_160275# VSS VSS nfet_06v0 ad=13p pd=50.52u as=13p ps=50.52u w=50u l=0.7u
X176 a_33684_148611# ESD_RAIL ESD_RAIL VSS nfet_06v0 ad=13p pd=50.52u as=13p ps=50.52u w=50u l=0.7u
X177 a_33684_160275# a_33684_148611# a_33684_148611# VSS nfet_06v0 ad=13p pd=50.52u as=13p ps=50.52u w=50u l=0.7u
X178 VSS a_33684_160275# a_33684_160275# VSS nfet_06v0 ad=13p pd=50.52u as=13p ps=50.52u w=50u l=0.7u
X179 VSS a_33684_160275# a_33684_160275# VSS nfet_06v0 ad=13p pd=50.52u as=13p ps=50.52u w=50u l=0.7u
X180 POST_TAIL_3 POST_BIAS VSS VSS nfet_03v3 ad=8.8p pd=40.88u as=8.8p ps=40.88u w=20u l=1u
X181 a_33684_148611# ESD_RAIL ESD_RAIL VSS nfet_06v0 ad=13p pd=50.52u as=13p ps=50.52u w=50u l=0.7u
X182 a_33684_160275# a_33684_160275# VSS VSS nfet_06v0 ad=13p pd=50.52u as=13p ps=50.52u w=50u l=0.7u
X183 a_35813_117064# a_33005_131545# ESD_RAIL ESD_RAIL pfet_06v0 ad=1.3p pd=5.52u as=1.3p ps=5.52u w=5u l=0.7u
X184 a_33684_160275# a_33684_148611# a_33684_148611# VSS nfet_06v0 ad=13p pd=50.52u as=13p ps=50.52u w=50u l=0.7u
X185 a_33684_148611# a_33684_148611# a_33684_160275# VSS nfet_06v0 ad=13p pd=50.52u as=13p ps=50.52u w=50u l=0.7u
X186 a_34245_90628# a_36789_117064# ESD_RAIL ESD_RAIL pfet_06v0 ad=1.3p pd=5.52u as=1.3p ps=5.52u w=5u l=0.7u
X187 a_33684_148611# ESD_RAIL ESD_RAIL VSS nfet_06v0 ad=13p pd=50.52u as=13p ps=50.52u w=50u l=0.7u
X188 VSS a_33684_160275# a_33684_160275# VSS nfet_06v0 ad=13p pd=50.52u as=13p ps=50.52u w=50u l=0.7u
X189 a_33684_148611# a_33684_148611# a_33684_160275# VSS nfet_06v0 ad=13p pd=50.52u as=13p ps=50.52u w=50u l=0.7u
X190 PAD_P CASCODE SUM_P_D_7 VSS nfet_06v0 ad=7.04p pd=32.88u as=7.04p ps=32.88u w=16u l=0.7u
X191 a_33684_160275# a_33684_160275# VSS VSS nfet_06v0 ad=13p pd=50.52u as=13p ps=50.52u w=50u l=0.7u
X192 a_33684_160275# a_33684_160275# VSS VSS nfet_06v0 ad=13p pd=50.52u as=13p ps=50.52u w=50u l=0.7u
X193 PAD_P CASCODE SUM_P_D_0 VSS nfet_06v0 ad=7.04p pd=32.88u as=7.04p ps=32.88u w=16u l=0.7u
X194 VSS a_33684_160275# a_33684_160275# VSS nfet_06v0 ad=13p pd=50.52u as=13p ps=50.52u w=50u l=0.7u
X195 VSS a_34245_90628# ESD_RAIL VSS nfet_06v0 ad=13p pd=50.52u as=13p ps=50.52u w=50u l=0.7u
X196 SUM_P_D_1 TMDS_P TMDS_TAIL_1 VSS nfet_03v3 ad=8.8p pd=40.88u as=8.8p ps=40.88u w=20u l=0.28u
X197 VSS a_33684_160275# a_33684_160275# VSS nfet_06v0 ad=13p pd=50.52u as=13p ps=50.52u w=50u l=0.7u
X198 MAIN_TAIL_0 MAIN_BIAS VSS VSS nfet_03v3 ad=8.8p pd=40.88u as=8.8p ps=40.88u w=20u l=1u
X199 a_33684_148611# a_33684_148611# a_33684_160275# VSS nfet_06v0 ad=13p pd=50.52u as=13p ps=50.52u w=50u l=0.7u
X200 VSS ESD_RAIL VSS ppolyf_u_1k_6p0 r_width=1u r_length=9.98874m
X201 a_33684_160275# a_33684_160275# VSS VSS nfet_06v0 ad=13p pd=50.52u as=22p ps=0.10088m w=50u l=0.7u
X202 a_33684_160275# a_33684_160275# VSS VSS nfet_06v0 ad=13p pd=50.52u as=13p ps=50.52u w=50u l=0.7u
X203 a_36789_117064# a_35813_117064# ESD_RAIL ESD_RAIL pfet_06v0 ad=2.2p pd=10.88u as=1.3p ps=5.52u w=5u l=0.7u
X204 VSS a_33684_160275# a_33684_160275# VSS nfet_06v0 ad=13p pd=50.52u as=13p ps=50.52u w=50u l=0.7u
X205 PAD_P CASCODE SUM_P_D_2 VSS nfet_06v0 ad=7.04p pd=32.88u as=7.04p ps=32.88u w=16u l=0.7u
X206 MAIN_TAIL_1 MAIN_BIAS VSS VSS nfet_03v3 ad=8.8p pd=40.88u as=8.8p ps=40.88u w=20u l=1u
X207 ESD_RAIL ESD_RAIL a_33684_148611# VSS nfet_06v0 ad=13p pd=50.52u as=13p ps=50.52u w=50u l=0.7u
X208 POST_TAIL_2 POST_BIAS VSS VSS nfet_03v3 ad=8.8p pd=40.88u as=8.8p ps=40.88u w=20u l=1u
X209 a_33684_148611# a_33684_148611# a_33684_160275# VSS nfet_06v0 ad=13p pd=50.52u as=13p ps=50.52u w=50u l=0.7u
X210 a_33684_160275# a_33684_148611# a_33684_148611# VSS nfet_06v0 ad=13p pd=50.52u as=13p ps=50.52u w=50u l=0.7u
D4 VSS PAD_N diode_nd2ps_06v0 pj=51.8u area=22.5p
X211 ESD_RAIL a_34245_90628# VSS VSS nfet_06v0 ad=13p pd=50.52u as=13p ps=50.52u w=50u l=0.7u
X212 ESD_RAIL a_36789_117064# a_34245_90628# ESD_RAIL pfet_06v0 ad=1.3p pd=5.52u as=1.3p ps=5.52u w=5u l=0.7u
X213 VSS a_33684_160275# a_33684_160275# VSS nfet_06v0 ad=13p pd=50.52u as=13p ps=50.52u w=50u l=0.7u
X214 ESD_RAIL ATB_ESD_RAIL VSS ppolyf_u_1k_6p0 r_width=1u r_length=0.47474m
X215 SUM_N_D_0 MAIN_N MAIN_TAIL_0 VSS nfet_03v3 ad=8.8p pd=40.88u as=8.8p ps=40.88u w=20u l=0.28u
X216 a_33684_148611# ESD_RAIL ESD_RAIL VSS nfet_06v0 ad=13p pd=50.52u as=13p ps=50.52u w=50u l=0.7u
X217 a_33684_160275# a_33684_160275# VSS VSS nfet_06v0 ad=13p pd=50.52u as=13p ps=50.52u w=50u l=0.7u
X218 TERM_N_R TERM_ENABLE_LOCAL TERM_VCM VSS nfet_03v3 ad=8.8p pd=40.88u as=8.8p ps=40.88u w=20u l=0.28u
X219 a_33684_160275# a_33684_160275# VSS VSS nfet_06v0 ad=13p pd=50.52u as=13p ps=50.52u w=50u l=0.7u
D5 VSS PAD_N diode_nd2ps_06v0 pj=51.8u area=22.5p
X220 ESD_RAIL ESD_RAIL a_33684_148611# VSS nfet_06v0 ad=13p pd=50.52u as=13p ps=50.52u w=50u l=0.7u
X221 a_33684_160275# a_33684_148611# a_33684_148611# VSS nfet_06v0 ad=13p pd=50.52u as=13p ps=50.52u w=50u l=0.7u
X222 a_33684_148611# ESD_RAIL ESD_RAIL VSS nfet_06v0 ad=13p pd=50.52u as=13p ps=50.52u w=50u l=0.7u
X223 VSS a_33684_160275# a_33684_160275# VSS nfet_06v0 ad=13p pd=50.52u as=13p ps=50.52u w=50u l=0.7u
X224 VSS a_33684_160275# a_33684_160275# VSS nfet_06v0 ad=13p pd=50.52u as=13p ps=50.52u w=50u l=0.7u
X225 PAD_P CASCODE SUM_P_D_5 VSS nfet_06v0 ad=7.04p pd=32.88u as=7.04p ps=32.88u w=16u l=0.7u
X226 a_33684_148611# ESD_RAIL ESD_RAIL VSS nfet_06v0 ad=13p pd=50.52u as=13p ps=50.52u w=50u l=0.7u
X227 a_33684_160275# a_33684_160275# VSS VSS nfet_06v0 ad=13p pd=50.52u as=13p ps=50.52u w=50u l=0.7u
X228 POST_TAIL_2 POST_BIAS VSS VSS nfet_03v3 ad=8.8p pd=40.88u as=8.8p ps=40.88u w=20u l=1u
X229 ESD_RAIL ESD_RAIL a_33684_148611# VSS nfet_06v0 ad=13p pd=50.52u as=13p ps=50.52u w=50u l=0.7u
X230 a_33684_160275# a_33684_160275# VSS VSS nfet_06v0 ad=13p pd=50.52u as=13p ps=50.52u w=50u l=0.7u
X231 a_33684_160275# a_33684_148611# a_33684_148611# VSS nfet_06v0 ad=13p pd=50.52u as=13p ps=50.52u w=50u l=0.7u
X232 a_33684_148611# a_33684_148611# a_33684_160275# VSS nfet_06v0 ad=13p pd=50.52u as=13p ps=50.52u w=50u l=0.7u
X233 a_33684_160275# a_33684_160275# VSS VSS nfet_06v0 ad=13p pd=50.52u as=13p ps=50.52u w=50u l=0.7u
X234 MAIN_TAIL_2 MAIN_BIAS VSS VSS nfet_03v3 ad=8.8p pd=40.88u as=8.8p ps=40.88u w=20u l=1u
X235 VSS a_33684_160275# a_33684_160275# VSS nfet_06v0 ad=13p pd=50.52u as=13p ps=50.52u w=50u l=0.7u
X236 a_33684_148611# ESD_RAIL ESD_RAIL VSS nfet_06v0 ad=13p pd=50.52u as=13p ps=50.52u w=50u l=0.7u
X237 a_33684_148611# a_33684_148611# a_33684_160275# VSS nfet_06v0 ad=13p pd=50.52u as=13p ps=50.52u w=50u l=0.7u
X238 ESD_RAIL a_36789_117064# a_34245_90628# ESD_RAIL pfet_06v0 ad=2.2p pd=10.88u as=1.3p ps=5.52u w=5u l=0.7u
X239 MAIN_TAIL_0 MAIN_BIAS VSS VSS nfet_03v3 ad=8.8p pd=40.88u as=8.8p ps=40.88u w=20u l=1u
X240 a_33684_160275# a_33684_160275# VSS VSS nfet_06v0 ad=13p pd=50.52u as=13p ps=50.52u w=50u l=0.7u
X241 ESD_RAIL ESD_RAIL a_33684_148611# VSS nfet_06v0 ad=13p pd=50.52u as=13p ps=50.52u w=50u l=0.7u
X242 VSS a_34245_90628# ESD_RAIL VSS nfet_06v0 ad=13p pd=50.52u as=13p ps=50.52u w=50u l=0.7u
X243 ESD_RAIL ESD_RAIL a_33684_148611# VSS nfet_06v0 ad=13p pd=50.52u as=13p ps=50.52u w=50u l=0.7u
X244 VSS a_33684_160275# a_33684_160275# VSS nfet_06v0 ad=13p pd=50.52u as=13p ps=50.52u w=50u l=0.7u
X245 a_33684_148611# ESD_RAIL ESD_RAIL VSS nfet_06v0 ad=13p pd=50.52u as=13p ps=50.52u w=50u l=0.7u
X246 ESD_RAIL a_34245_90628# VSS VSS nfet_06v0 ad=13p pd=50.52u as=13p ps=50.52u w=50u l=0.7u
X247 a_33684_148611# ESD_RAIL ESD_RAIL VSS nfet_06v0 ad=13p pd=50.52u as=13p ps=50.52u w=50u l=0.7u
X248 VSS a_33684_160275# a_33684_160275# VSS nfet_06v0 ad=13p pd=50.52u as=13p ps=50.52u w=50u l=0.7u
X249 a_33684_148611# a_33684_148611# a_33684_160275# VSS nfet_06v0 ad=13p pd=50.52u as=13p ps=50.52u w=50u l=0.7u
X250 ESD_RAIL ESD_RAIL a_33684_148611# VSS nfet_06v0 ad=13p pd=50.52u as=22p ps=0.10088m w=50u l=0.7u
X251 SUM_P_D_0 TMDS_P TMDS_TAIL_0 VSS nfet_03v3 ad=8.8p pd=40.88u as=8.8p ps=40.88u w=20u l=0.28u
X252 a_33684_160275# a_33684_160275# VSS VSS nfet_06v0 ad=13p pd=50.52u as=13p ps=50.52u w=50u l=0.7u
X253 VSS a_33684_160275# a_33684_160275# VSS nfet_06v0 ad=13p pd=50.52u as=13p ps=50.52u w=50u l=0.7u
X254 a_33684_160275# a_33684_160275# VSS VSS nfet_06v0 ad=13p pd=50.52u as=13p ps=50.52u w=50u l=0.7u
X255 a_33005_134065# a_45878_133785# ESD_RAIL ppolyf_u r_width=0.8u r_length=63.855u
X256 MAIN_TAIL_6 MAIN_BIAS VSS VSS nfet_03v3 ad=8.8p pd=40.88u as=8.8p ps=40.88u w=20u l=1u
X257 ESD_RAIL ESD_RAIL a_33684_148611# VSS nfet_06v0 ad=13p pd=50.52u as=13p ps=50.52u w=50u l=0.7u
X258 TERM_ENABLE_LOCAL TERM_ENABLE_B VSS VSS nfet_06v0 ad=0.88p pd=4.88u as=0.88p ps=4.88u w=2u l=0.7u
X259 VSS a_33684_160275# a_33684_160275# VSS nfet_06v0 ad=13p pd=50.52u as=13p ps=50.52u w=50u l=0.7u
X260 a_33684_148611# ESD_RAIL ESD_RAIL VSS nfet_06v0 ad=13p pd=50.52u as=13p ps=50.52u w=50u l=0.7u
X261 a_33684_160275# a_33684_160275# VSS VSS nfet_06v0 ad=13p pd=50.52u as=13p ps=50.52u w=50u l=0.7u
X262 VSS a_33684_160275# a_33684_160275# VSS nfet_06v0 ad=13p pd=50.52u as=13p ps=50.52u w=50u l=0.7u
X263 a_33684_160275# a_33684_160275# VSS VSS nfet_06v0 ad=13p pd=50.52u as=13p ps=50.52u w=50u l=0.7u
X264 a_33684_148611# ESD_RAIL ESD_RAIL VSS nfet_06v0 ad=13p pd=50.52u as=13p ps=50.52u w=50u l=0.7u
X265 DETECT_ENABLE_B DETECT_ENABLE VDD VDD pfet_06v0 ad=1.76p pd=8.88u as=1.76p ps=8.88u w=4u l=0.55u
X266 a_33684_160275# a_33684_160275# VSS VSS nfet_06v0 ad=13p pd=50.52u as=13p ps=50.52u w=50u l=0.7u
X267 ESD_RAIL ESD_RAIL a_33684_148611# VSS nfet_06v0 ad=13p pd=50.52u as=13p ps=50.52u w=50u l=0.7u
X268 TERM_N_R TERM_ENABLE_LOCAL TERM_VCM VSS nfet_03v3 ad=8.8p pd=40.88u as=8.8p ps=40.88u w=20u l=0.28u
X269 VSS a_34245_90628# ESD_RAIL VSS nfet_06v0 ad=13p pd=50.52u as=13p ps=50.52u w=50u l=0.7u
X270 ESD_RAIL ESD_RAIL a_33684_148611# VSS nfet_06v0 ad=13p pd=50.52u as=13p ps=50.52u w=50u l=0.7u
X271 SUM_P_D_6 POST_P POST_TAIL_6 VSS nfet_03v3 ad=8.8p pd=40.88u as=8.8p ps=40.88u w=20u l=0.28u
X272 VSS a_34245_90628# ESD_RAIL VSS nfet_06v0 ad=13p pd=50.52u as=13p ps=50.52u w=50u l=0.7u
X273 VSS a_33684_160275# a_33684_160275# VSS nfet_06v0 ad=13p pd=50.52u as=13p ps=50.52u w=50u l=0.7u
X274 a_33684_160275# a_33684_160275# VSS VSS nfet_06v0 ad=13p pd=50.52u as=13p ps=50.52u w=50u l=0.7u
X275 VSS a_33684_160275# a_33684_160275# VSS nfet_06v0 ad=13p pd=50.52u as=13p ps=50.52u w=50u l=0.7u
X276 a_33684_148611# ESD_RAIL ESD_RAIL VSS nfet_06v0 ad=13p pd=50.52u as=13p ps=50.52u w=50u l=0.7u
X277 a_33684_148611# ESD_RAIL ESD_RAIL VSS nfet_06v0 ad=13p pd=50.52u as=13p ps=50.52u w=50u l=0.7u
X278 a_33684_160275# a_33684_160275# VSS VSS nfet_06v0 ad=13p pd=50.52u as=13p ps=50.52u w=50u l=0.7u
X279 ESD_RAIL ESD_RAIL a_33684_148611# VSS nfet_06v0 ad=13p pd=50.52u as=13p ps=50.52u w=50u l=0.7u
X280 ESD_RAIL ESD_RAIL a_33684_148611# VSS nfet_06v0 ad=13p pd=50.52u as=13p ps=50.52u w=50u l=0.7u
X281 a_33684_160275# a_33684_160275# VSS VSS nfet_06v0 ad=13p pd=50.52u as=13p ps=50.52u w=50u l=0.7u
D6 VSS ESD_RAIL diode_nd2ps_06v0 pj=82u area=40p
X282 VSS a_33684_160275# a_33684_160275# VSS nfet_06v0 ad=13p pd=50.52u as=13p ps=50.52u w=50u l=0.7u
X283 ESD_RAIL ESD_RAIL a_33684_148611# VSS nfet_06v0 ad=13p pd=50.52u as=13p ps=50.52u w=50u l=0.7u
X284 TMDS_TAIL_5 TMDS_BIAS VSS VSS nfet_03v3 ad=8.8p pd=40.88u as=8.8p ps=40.88u w=20u l=1u
X285 ESD_RAIL a_35813_117064# a_36789_117064# ESD_RAIL pfet_06v0 ad=1.3p pd=5.52u as=1.3p ps=5.52u w=5u l=0.7u
X286 a_33684_148611# ESD_RAIL ESD_RAIL VSS nfet_06v0 ad=13p pd=50.52u as=13p ps=50.52u w=50u l=0.7u
X287 a_33684_148611# a_33684_148611# a_33684_160275# VSS nfet_06v0 ad=13p pd=50.52u as=13p ps=50.52u w=50u l=0.7u
X288 a_33684_148611# a_33684_148611# a_33684_160275# VSS nfet_06v0 ad=13p pd=50.52u as=13p ps=50.52u w=50u l=0.7u
X289 TERM_ENABLE_LOCAL TERM_BLEED_0 VSS ppolyf_u_1k r_width=1u r_length=12.5u
X290 a_33684_160275# a_33684_160275# VSS VSS nfet_06v0 ad=13p pd=50.52u as=13p ps=50.52u w=50u l=0.7u
X291 MAIN_TAIL_5 MAIN_BIAS VSS VSS nfet_03v3 ad=8.8p pd=40.88u as=8.8p ps=40.88u w=20u l=1u
X292 SUM_P_D_4 POST_P POST_TAIL_4 VSS nfet_03v3 ad=8.8p pd=40.88u as=8.8p ps=40.88u w=20u l=0.28u
X293 VSS a_33684_160275# a_33684_160275# VSS nfet_06v0 ad=13p pd=50.52u as=13p ps=50.52u w=50u l=0.7u
X294 ESD_RAIL ESD_RAIL a_33684_148611# VSS nfet_06v0 ad=13p pd=50.52u as=13p ps=50.52u w=50u l=0.7u
X295 a_33684_148611# ESD_RAIL ESD_RAIL VSS nfet_06v0 ad=13p pd=50.52u as=13p ps=50.52u w=50u l=0.7u
X296 VSS a_34245_90628# ESD_RAIL VSS nfet_06v0 ad=13p pd=50.52u as=13p ps=50.52u w=50u l=0.7u
X297 POST_TAIL_0 POST_BIAS VSS VSS nfet_03v3 ad=8.8p pd=40.88u as=8.8p ps=40.88u w=20u l=1u
D7 VSS PAD_N diode_nd2ps_06v0 pj=51.8u area=22.5p
X298 a_33684_148611# ESD_RAIL ESD_RAIL VSS nfet_06v0 ad=13p pd=50.52u as=13p ps=50.52u w=50u l=0.7u
X299 ESD_RAIL ESD_RAIL a_33684_148611# VSS nfet_06v0 ad=13p pd=50.52u as=13p ps=50.52u w=50u l=0.7u
D8 PAD_P ESD_RAIL diode_pd2nw_06v0 pj=51.8u area=22.5p
X300 a_34245_90628# a_36789_117064# ESD_RAIL ESD_RAIL pfet_06v0 ad=1.3p pd=5.52u as=1.3p ps=5.52u w=5u l=0.7u
X301 VSS a_34245_90628# ESD_RAIL VSS nfet_06v0 ad=13p pd=50.52u as=13p ps=50.52u w=50u l=0.7u
X302 SUM_P_D_1 MAIN_P MAIN_TAIL_1 VSS nfet_03v3 ad=8.8p pd=40.88u as=8.8p ps=40.88u w=20u l=0.28u
X303 ESD_RAIL ESD_RAIL a_33684_148611# VSS nfet_06v0 ad=13p pd=50.52u as=13p ps=50.52u w=50u l=0.7u
X304 a_33684_148611# ESD_RAIL ESD_RAIL VSS nfet_06v0 ad=13p pd=50.52u as=13p ps=50.52u w=50u l=0.7u
X305 TERM_BLEED_1 TERM_BLEED_2 VSS ppolyf_u_1k r_width=1u r_length=12.5u
X306 a_33684_148611# a_33684_148611# a_33684_160275# VSS nfet_06v0 ad=13p pd=50.52u as=13p ps=50.52u w=50u l=0.7u
X307 PAD_N CASCODE SUM_N_D_2 VSS nfet_06v0 ad=7.04p pd=32.88u as=7.04p ps=32.88u w=16u l=0.7u
X308 a_33684_148611# ESD_RAIL ESD_RAIL VSS nfet_06v0 ad=13p pd=50.52u as=13p ps=50.52u w=50u l=0.7u
X309 ESD_RAIL ESD_RAIL a_33684_148611# VSS nfet_06v0 ad=13p pd=50.52u as=13p ps=50.52u w=50u l=0.7u
X310 a_33684_160275# a_33684_148611# a_33684_148611# VSS nfet_06v0 ad=13p pd=50.52u as=13p ps=50.52u w=50u l=0.7u
X311 VSS a_33684_160275# a_33684_160275# VSS nfet_06v0 ad=13p pd=50.52u as=13p ps=50.52u w=50u l=0.7u
X312 a_33684_160275# a_33684_160275# VSS VSS nfet_06v0 ad=13p pd=50.52u as=13p ps=50.52u w=50u l=0.7u
X313 a_33684_148611# a_33684_148611# a_33684_160275# VSS nfet_06v0 ad=13p pd=50.52u as=13p ps=50.52u w=50u l=0.7u
X314 ESD_RAIL ESD_RAIL a_33684_148611# VSS nfet_06v0 ad=13p pd=50.52u as=13p ps=50.52u w=50u l=0.7u
X315 a_33684_148611# ESD_RAIL ESD_RAIL VSS nfet_06v0 ad=13p pd=50.52u as=13p ps=50.52u w=50u l=0.7u
X316 a_33684_148611# a_33684_148611# a_33684_160275# VSS nfet_06v0 ad=13p pd=50.52u as=13p ps=50.52u w=50u l=0.7u
X317 a_35813_117064# a_33005_131545# ESD_RAIL ESD_RAIL pfet_06v0 ad=1.3p pd=5.52u as=2.2p ps=10.88u w=5u l=0.7u
X318 ESD_RAIL ESD_RAIL a_33684_148611# VSS nfet_06v0 ad=13p pd=50.52u as=13p ps=50.52u w=50u l=0.7u
X319 a_33684_160275# a_33684_148611# a_33684_148611# VSS nfet_06v0 ad=13p pd=50.52u as=13p ps=50.52u w=50u l=0.7u
X320 a_33684_160275# a_33684_148611# a_33684_148611# VSS nfet_06v0 ad=13p pd=50.52u as=13p ps=50.52u w=50u l=0.7u
X321 ESD_RAIL a_34245_90628# VSS VSS nfet_06v0 ad=22p pd=0.10088m as=13p ps=50.52u w=50u l=0.7u
X322 a_33684_148611# a_33684_148611# a_33684_160275# VSS nfet_06v0 ad=13p pd=50.52u as=13p ps=50.52u w=50u l=0.7u
X323 a_33684_148611# ESD_RAIL ESD_RAIL VSS nfet_06v0 ad=13p pd=50.52u as=13p ps=50.52u w=50u l=0.7u
X324 MAIN_TAIL_4 MAIN_BIAS VSS VSS nfet_03v3 ad=8.8p pd=40.88u as=8.8p ps=40.88u w=20u l=1u
X325 a_33684_148611# ESD_RAIL ESD_RAIL VSS nfet_06v0 ad=13p pd=50.52u as=13p ps=50.52u w=50u l=0.7u
X326 ESD_RAIL ESD_RAIL a_33684_148611# VSS nfet_06v0 ad=13p pd=50.52u as=13p ps=50.52u w=50u l=0.7u
X327 a_33684_160275# a_33684_148611# a_33684_148611# VSS nfet_06v0 ad=13p pd=50.52u as=13p ps=50.52u w=50u l=0.7u
X328 ESD_RAIL ESD_RAIL a_33684_148611# VSS nfet_06v0 ad=13p pd=50.52u as=13p ps=50.52u w=50u l=0.7u
X329 ESD_RAIL a_34245_90628# VSS VSS nfet_06v0 ad=13p pd=50.52u as=13p ps=50.52u w=50u l=0.7u
X330 ESD_RAIL ESD_RAIL a_33684_148611# VSS nfet_06v0 ad=13p pd=50.52u as=13p ps=50.52u w=50u l=0.7u
X331 DETECT_ENABLE_B DETECT_ENABLE VSS VSS nfet_06v0 ad=0.88p pd=4.88u as=0.88p ps=4.88u w=2u l=0.7u
X332 a_33684_148611# a_33684_148611# a_33684_160275# VSS nfet_06v0 ad=13p pd=50.52u as=13p ps=50.52u w=50u l=0.7u
X333 SUM_P_D_3 POST_P POST_TAIL_3 VSS nfet_03v3 ad=8.8p pd=40.88u as=8.8p ps=40.88u w=20u l=0.28u
X334 a_33684_148611# ESD_RAIL ESD_RAIL VSS nfet_06v0 ad=13p pd=50.52u as=13p ps=50.52u w=50u l=0.7u
X335 a_33684_160275# a_33684_148611# a_33684_148611# VSS nfet_06v0 ad=13p pd=50.52u as=13p ps=50.52u w=50u l=0.7u
X336 TERM_P_R TERM_ENABLE_LOCAL TERM_VCM VSS nfet_03v3 ad=8.8p pd=40.88u as=8.8p ps=40.88u w=20u l=0.28u
X337 TMDS_TAIL_4 TMDS_BIAS VSS VSS nfet_03v3 ad=8.8p pd=40.88u as=8.8p ps=40.88u w=20u l=1u
X338 a_33684_148611# a_33684_148611# a_33684_160275# VSS nfet_06v0 ad=13p pd=50.52u as=13p ps=50.52u w=50u l=0.7u
X339 a_33684_148611# a_33684_148611# a_33684_160275# VSS nfet_06v0 ad=13p pd=50.52u as=13p ps=50.52u w=50u l=0.7u
X340 a_36789_117064# a_35813_117064# ESD_RAIL ESD_RAIL pfet_06v0 ad=1.3p pd=5.52u as=1.3p ps=5.52u w=5u l=0.7u
X341 ESD_RAIL ESD_RAIL a_33684_148611# VSS nfet_06v0 ad=13p pd=50.52u as=13p ps=50.52u w=50u l=0.7u
X342 a_33684_160275# a_33684_148611# a_33684_148611# VSS nfet_06v0 ad=13p pd=50.52u as=13p ps=50.52u w=50u l=0.7u
X343 a_33684_148611# ESD_RAIL ESD_RAIL VSS nfet_06v0 ad=13p pd=50.52u as=13p ps=50.52u w=50u l=0.7u
X344 a_33684_148611# a_33684_148611# a_33684_160275# VSS nfet_06v0 ad=13p pd=50.52u as=13p ps=50.52u w=50u l=0.7u
X345 a_33684_160275# a_33684_160275# VSS VSS nfet_06v0 ad=13p pd=50.52u as=13p ps=50.52u w=50u l=0.7u
X346 a_33684_148611# a_33684_148611# a_33684_160275# VSS nfet_06v0 ad=13p pd=50.52u as=13p ps=50.52u w=50u l=0.7u
X347 a_33684_160275# a_33684_148611# a_33684_148611# VSS nfet_06v0 ad=13p pd=50.52u as=13p ps=50.52u w=50u l=0.7u
X348 a_33684_160275# a_33684_148611# a_33684_148611# VSS nfet_06v0 ad=13p pd=50.52u as=13p ps=50.52u w=50u l=0.7u
X349 a_33684_148611# a_33684_148611# a_33684_160275# VSS nfet_06v0 ad=13p pd=50.52u as=13p ps=50.52u w=50u l=0.7u
X350 a_33684_160275# a_33684_148611# a_33684_148611# VSS nfet_06v0 ad=13p pd=50.52u as=13p ps=50.52u w=50u l=0.7u
X351 SUM_P_D_7 MAIN_P MAIN_TAIL_7 VSS nfet_03v3 ad=8.8p pd=40.88u as=8.8p ps=40.88u w=20u l=0.28u
X352 VSS a_33684_160275# a_33684_160275# VSS nfet_06v0 ad=13p pd=50.52u as=13p ps=50.52u w=50u l=0.7u
X353 MAIN_TAIL_3 MAIN_BIAS VSS VSS nfet_03v3 ad=8.8p pd=40.88u as=8.8p ps=40.88u w=20u l=1u
X354 a_33684_148611# ESD_RAIL ESD_RAIL VSS nfet_06v0 ad=13p pd=50.52u as=13p ps=50.52u w=50u l=0.7u
X355 a_33684_148611# a_33684_148611# a_33684_160275# VSS nfet_06v0 ad=13p pd=50.52u as=13p ps=50.52u w=50u l=0.7u
X356 ESD_RAIL ESD_RAIL a_33684_148611# VSS nfet_06v0 ad=13p pd=50.52u as=13p ps=50.52u w=50u l=0.7u
X357 a_33684_160275# a_33684_148611# a_33684_148611# VSS nfet_06v0 ad=13p pd=50.52u as=13p ps=50.52u w=50u l=0.7u
X358 a_33684_148611# a_33684_148611# a_33684_160275# VSS nfet_06v0 ad=13p pd=50.52u as=13p ps=50.52u w=50u l=0.7u
X359 a_33684_160275# a_33684_148611# a_33684_148611# VSS nfet_06v0 ad=13p pd=50.52u as=13p ps=50.52u w=50u l=0.7u
X360 TMDS_TAIL_2 TMDS_BIAS VSS VSS nfet_03v3 ad=8.8p pd=40.88u as=8.8p ps=40.88u w=20u l=1u
X361 a_33684_148611# a_33684_148611# a_33684_160275# VSS nfet_06v0 ad=13p pd=50.52u as=13p ps=50.52u w=50u l=0.7u
X362 a_33684_160275# a_33684_148611# a_33684_148611# VSS nfet_06v0 ad=13p pd=50.52u as=13p ps=50.52u w=50u l=0.7u
X363 VSS a_34245_90628# ESD_RAIL VSS nfet_06v0 ad=13p pd=50.52u as=22p ps=0.10088m w=50u l=0.7u
X364 MAIN_TAIL_3 MAIN_BIAS VSS VSS nfet_03v3 ad=8.8p pd=40.88u as=8.8p ps=40.88u w=20u l=1u
X365 DETECT_ENABLE_LOCAL DETECT_BLEED_0 VSS ppolyf_u_1k r_width=1u r_length=12.5u
X366 a_33684_160275# a_33684_148611# a_33684_148611# VSS nfet_06v0 ad=13p pd=50.52u as=13p ps=50.52u w=50u l=0.7u
X367 a_33684_148611# a_33684_148611# a_33684_160275# VSS nfet_06v0 ad=13p pd=50.52u as=13p ps=50.52u w=50u l=0.7u
X368 VSS a_34245_90628# ESD_RAIL VSS nfet_06v0 ad=13p pd=50.52u as=13p ps=50.52u w=50u l=0.7u
X369 ESD_RAIL a_36789_117064# a_34245_90628# ESD_RAIL pfet_06v0 ad=1.3p pd=5.52u as=1.3p ps=5.52u w=5u l=0.7u
X370 a_33684_160275# a_33684_160275# VSS VSS nfet_06v0 ad=13p pd=50.52u as=13p ps=50.52u w=50u l=0.7u
X371 a_33684_160275# a_33684_148611# a_33684_148611# VSS nfet_06v0 ad=13p pd=50.52u as=13p ps=50.52u w=50u l=0.7u
X372 a_34245_90628# a_36789_117064# ESD_RAIL ESD_RAIL pfet_06v0 ad=1.3p pd=5.52u as=1.3p ps=5.52u w=5u l=0.7u
X373 a_33684_160275# a_33684_148611# a_33684_148611# VSS nfet_06v0 ad=13p pd=50.52u as=13p ps=50.52u w=50u l=0.7u
X374 VSS a_34245_90628# ESD_RAIL VSS nfet_06v0 ad=13p pd=50.52u as=13p ps=50.52u w=50u l=0.7u
X375 a_33684_148611# a_33684_148611# a_33684_160275# VSS nfet_06v0 ad=13p pd=50.52u as=13p ps=50.52u w=50u l=0.7u
D9 PAD_P ESD_RAIL diode_pd2nw_06v0 pj=51.8u area=22.5p
X376 a_33684_160275# a_33684_148611# a_33684_148611# VSS nfet_06v0 ad=13p pd=50.52u as=13p ps=50.52u w=50u l=0.7u
X377 a_33684_148611# a_33684_148611# a_33684_160275# VSS nfet_06v0 ad=13p pd=50.52u as=13p ps=50.52u w=50u l=0.7u
X378 ESD_RAIL ESD_RAIL a_33684_148611# VSS nfet_06v0 ad=13p pd=50.52u as=13p ps=50.52u w=50u l=0.7u
X379 a_33684_148611# a_33684_148611# a_33684_160275# VSS nfet_06v0 ad=13p pd=50.52u as=13p ps=50.52u w=50u l=0.7u
X380 a_33684_160275# a_33684_148611# a_33684_148611# VSS nfet_06v0 ad=13p pd=50.52u as=13p ps=50.52u w=50u l=0.7u
X381 VSS a_34245_90628# ESD_RAIL VSS nfet_06v0 ad=13p pd=50.52u as=13p ps=50.52u w=50u l=0.7u
X382 a_33684_148611# a_33684_148611# a_33684_160275# VSS nfet_06v0 ad=13p pd=50.52u as=13p ps=50.52u w=50u l=0.7u
X383 a_33684_148611# a_33684_148611# a_33684_160275# VSS nfet_06v0 ad=13p pd=50.52u as=13p ps=50.52u w=50u l=0.7u
X384 a_33684_160275# a_33684_148611# a_33684_148611# VSS nfet_06v0 ad=13p pd=50.52u as=13p ps=50.52u w=50u l=0.7u
X385 a_34245_90628# a_36789_117064# ESD_RAIL ESD_RAIL pfet_06v0 ad=1.3p pd=5.52u as=1.3p ps=5.52u w=5u l=0.7u
X386 VSS a_33684_160275# a_33684_160275# VSS nfet_06v0 ad=13p pd=50.52u as=13p ps=50.52u w=50u l=0.7u
X387 a_33684_148611# ESD_RAIL ESD_RAIL VSS nfet_06v0 ad=13p pd=50.52u as=13p ps=50.52u w=50u l=0.7u
X388 a_33684_148611# a_33684_148611# a_33684_160275# VSS nfet_06v0 ad=13p pd=50.52u as=13p ps=50.52u w=50u l=0.7u
X389 a_33684_160275# a_33684_148611# a_33684_148611# VSS nfet_06v0 ad=13p pd=50.52u as=13p ps=50.52u w=50u l=0.7u
X390 a_33684_148611# a_33684_148611# a_33684_160275# VSS nfet_06v0 ad=13p pd=50.52u as=13p ps=50.52u w=50u l=0.7u
X391 a_33684_160275# a_33684_160275# VSS VSS nfet_06v0 ad=13p pd=50.52u as=13p ps=50.52u w=50u l=0.7u
X392 ESD_RAIL a_34245_90628# VSS VSS nfet_06v0 ad=22p pd=0.10088m as=13p ps=50.52u w=50u l=0.7u
X393 VSS a_33684_160275# a_33684_160275# VSS nfet_06v0 ad=13p pd=50.52u as=13p ps=50.52u w=50u l=0.7u
X394 VSS a_33684_160275# a_33684_160275# VSS nfet_06v0 ad=13p pd=50.52u as=13p ps=50.52u w=50u l=0.7u
X395 a_33684_148611# a_33684_148611# a_33684_160275# VSS nfet_06v0 ad=13p pd=50.52u as=13p ps=50.52u w=50u l=0.7u
X396 SUM_N_D_2 TMDS_N TMDS_TAIL_2 VSS nfet_03v3 ad=8.8p pd=40.88u as=8.8p ps=40.88u w=20u l=0.28u
X397 ESD_RAIL a_34245_90628# VSS VSS nfet_06v0 ad=13p pd=50.52u as=13p ps=50.52u w=50u l=0.7u
D10 VSS PAD_P diode_nd2ps_06v0 pj=51.8u area=22.5p
X398 a_33684_160275# a_33684_160275# VSS VSS nfet_06v0 ad=13p pd=50.52u as=13p ps=50.52u w=50u l=0.7u
X399 VSS a_33684_160275# a_33684_160275# VSS nfet_06v0 ad=13p pd=50.52u as=13p ps=50.52u w=50u l=0.7u
X400 ESD_RAIL ESD_RAIL a_33684_148611# VSS nfet_06v0 ad=13p pd=50.52u as=13p ps=50.52u w=50u l=0.7u
X401 POST_TAIL_4 POST_BIAS VSS VSS nfet_03v3 ad=8.8p pd=40.88u as=8.8p ps=40.88u w=20u l=1u
X402 PAD_N CASCODE SUM_N_D_6 VSS nfet_06v0 ad=7.04p pd=32.88u as=7.04p ps=32.88u w=16u l=0.7u
X403 DETECT_ENABLE_LOCAL DETECT_ENABLE_B VDD VDD pfet_06v0 ad=1.76p pd=8.88u as=1.76p ps=8.88u w=4u l=0.55u
X404 a_33684_160275# a_33684_160275# VSS VSS nfet_06v0 ad=13p pd=50.52u as=13p ps=50.52u w=50u l=0.7u
X405 a_34245_90628# a_36789_117064# VSS VSS nfet_06v0 ad=1.3p pd=5.52u as=1.3p ps=5.52u w=5u l=0.7u
X406 VSS a_35813_117064# a_36789_117064# VSS nfet_06v0 ad=1.3p pd=5.52u as=1.3p ps=5.52u w=5u l=0.7u
X407 ESD_RAIL a_36789_117064# a_34245_90628# ESD_RAIL pfet_06v0 ad=1.3p pd=5.52u as=1.3p ps=5.52u w=5u l=0.7u
X408 a_33684_160275# a_33684_160275# VSS VSS nfet_06v0 ad=13p pd=50.52u as=13p ps=50.52u w=50u l=0.7u
X409 VSS a_33684_160275# a_33684_160275# VSS nfet_06v0 ad=13p pd=50.52u as=13p ps=50.52u w=50u l=0.7u
X410 POST_TAIL_7 POST_BIAS VSS VSS nfet_03v3 ad=8.8p pd=40.88u as=8.8p ps=40.88u w=20u l=1u
X411 VSS a_33684_160275# a_33684_160275# VSS nfet_06v0 ad=22p pd=0.10088m as=13p ps=50.52u w=50u l=0.7u
X412 a_33684_148611# a_33684_148611# a_33684_160275# VSS nfet_06v0 ad=13p pd=50.52u as=13p ps=50.52u w=50u l=0.7u
X413 SUM_P_D_5 MAIN_P MAIN_TAIL_5 VSS nfet_03v3 ad=8.8p pd=40.88u as=8.8p ps=40.88u w=20u l=0.28u
X414 a_33684_160275# a_33684_160275# VSS VSS nfet_06v0 ad=13p pd=50.52u as=13p ps=50.52u w=50u l=0.7u
X415 a_33684_160275# a_33684_160275# VSS VSS nfet_06v0 ad=13p pd=50.52u as=13p ps=50.52u w=50u l=0.7u
X416 VSS a_33684_160275# a_33684_160275# VSS nfet_06v0 ad=13p pd=50.52u as=13p ps=50.52u w=50u l=0.7u
X417 TERM_VCM VSS VSS ppolyf_u_1k r_width=2u r_length=2u
X418 VSS a_33684_160275# a_33684_160275# VSS nfet_06v0 ad=13p pd=50.52u as=13p ps=50.52u w=50u l=0.7u
X419 a_33684_160275# a_33684_160275# VSS VSS nfet_06v0 ad=13p pd=50.52u as=13p ps=50.52u w=50u l=0.7u
X420 VSS a_34245_90628# ESD_RAIL VSS nfet_06v0 ad=13p pd=50.52u as=13p ps=50.52u w=50u l=0.7u
X421 VSS a_33684_160275# a_33684_160275# VSS nfet_06v0 ad=13p pd=50.52u as=13p ps=50.52u w=50u l=0.7u
X422 a_33684_160275# a_33684_160275# VSS VSS nfet_06v0 ad=13p pd=50.52u as=13p ps=50.52u w=50u l=0.7u
X423 VSS a_33684_160275# a_33684_160275# VSS nfet_06v0 ad=13p pd=50.52u as=13p ps=50.52u w=50u l=0.7u
X424 a_33684_160275# a_33684_160275# VSS VSS nfet_06v0 ad=13p pd=50.52u as=13p ps=50.52u w=50u l=0.7u
X425 VSS a_36789_117064# a_34245_90628# VSS nfet_06v0 ad=1.3p pd=5.52u as=1.3p ps=5.52u w=5u l=0.7u
X426 a_33684_148611# ESD_RAIL ESD_RAIL VSS nfet_06v0 ad=13p pd=50.52u as=13p ps=50.52u w=50u l=0.7u
X427 a_33684_160275# a_33684_148611# a_33684_148611# VSS nfet_06v0 ad=13p pd=50.52u as=13p ps=50.52u w=50u l=0.7u
X428 ESD_RAIL a_34245_90628# VSS VSS nfet_06v0 ad=13p pd=50.52u as=13p ps=50.52u w=50u l=0.7u
X429 VSS a_33684_160275# a_33684_160275# VSS nfet_06v0 ad=13p pd=50.52u as=13p ps=50.52u w=50u l=0.7u
X430 a_33684_148611# ESD_RAIL ESD_RAIL VSS nfet_06v0 ad=13p pd=50.52u as=13p ps=50.52u w=50u l=0.7u
X431 ESD_RAIL ESD_RAIL a_33684_148611# VSS nfet_06v0 ad=13p pd=50.52u as=13p ps=50.52u w=50u l=0.7u
X432 TERM_N_R TERM_ENABLE_LOCAL TERM_VCM VSS nfet_03v3 ad=8.8p pd=40.88u as=8.8p ps=40.88u w=20u l=0.28u
X433 a_33684_160275# a_33684_160275# VSS VSS nfet_06v0 ad=13p pd=50.52u as=13p ps=50.52u w=50u l=0.7u
X434 VSS a_33684_160275# a_33684_160275# VSS nfet_06v0 ad=13p pd=50.52u as=13p ps=50.52u w=50u l=0.7u
X435 PAD_N CASCODE SUM_N_D_4 VSS nfet_06v0 ad=7.04p pd=32.88u as=7.04p ps=32.88u w=16u l=0.7u
X436 a_33684_148611# ESD_RAIL ESD_RAIL VSS nfet_06v0 ad=13p pd=50.52u as=13p ps=50.52u w=50u l=0.7u
X437 ESD_RAIL a_36789_117064# a_34245_90628# ESD_RAIL pfet_06v0 ad=1.3p pd=5.52u as=1.3p ps=5.52u w=5u l=0.7u
X438 SUM_N_D_3 TMDS_N TMDS_TAIL_3 VSS nfet_03v3 ad=8.8p pd=40.88u as=8.8p ps=40.88u w=20u l=0.28u
X439 VSS a_33684_160275# a_33684_160275# VSS nfet_06v0 ad=13p pd=50.52u as=13p ps=50.52u w=50u l=0.7u
X440 a_33684_148611# a_33684_148611# a_33684_160275# VSS nfet_06v0 ad=13p pd=50.52u as=13p ps=50.52u w=50u l=0.7u
X441 a_33684_160275# a_33684_160275# VSS VSS nfet_06v0 ad=13p pd=50.52u as=13p ps=50.52u w=50u l=0.7u
X442 VSS a_34245_90628# ESD_RAIL VSS nfet_06v0 ad=13p pd=50.52u as=13p ps=50.52u w=50u l=0.7u
X443 ESD_RAIL ESD_RAIL a_33684_148611# VSS nfet_06v0 ad=13p pd=50.52u as=13p ps=50.52u w=50u l=0.7u
X444 POST_TAIL_6 POST_BIAS VSS VSS nfet_03v3 ad=8.8p pd=40.88u as=8.8p ps=40.88u w=20u l=1u
X445 a_33684_160275# a_33684_160275# VSS VSS nfet_06v0 ad=13p pd=50.52u as=13p ps=50.52u w=50u l=0.7u
X446 VSS a_33684_160275# a_33684_160275# VSS nfet_06v0 ad=13p pd=50.52u as=13p ps=50.52u w=50u l=0.7u
X447 a_33005_131545# a_45878_131545# ESD_RAIL ppolyf_u r_width=0.8u r_length=63.855u
X448 a_33684_148611# ESD_RAIL ESD_RAIL VSS nfet_06v0 ad=13p pd=50.52u as=13p ps=50.52u w=50u l=0.7u
X449 SUM_P_D_4 MAIN_P MAIN_TAIL_4 VSS nfet_03v3 ad=8.8p pd=40.88u as=8.8p ps=40.88u w=20u l=0.28u
X450 a_33684_160275# a_33684_160275# VSS VSS nfet_06v0 ad=13p pd=50.52u as=13p ps=50.52u w=50u l=0.7u
X451 VSS a_34245_90628# ESD_RAIL VSS nfet_06v0 ad=13p pd=50.52u as=13p ps=50.52u w=50u l=0.7u
X452 PAD_N CASCODE SUM_N_D_7 VSS nfet_06v0 ad=7.04p pd=32.88u as=7.04p ps=32.88u w=16u l=0.7u
X453 ESD_RAIL ESD_RAIL a_33684_148611# VSS nfet_06v0 ad=13p pd=50.52u as=13p ps=50.52u w=50u l=0.7u
X454 a_33684_160275# a_33684_160275# VSS VSS nfet_06v0 ad=13p pd=50.52u as=13p ps=50.52u w=50u l=0.7u
X455 ESD_RAIL ESD_RAIL a_33684_148611# VSS nfet_06v0 ad=13p pd=50.52u as=13p ps=50.52u w=50u l=0.7u
X456 VSS a_33684_160275# a_33684_160275# VSS nfet_06v0 ad=13p pd=50.52u as=13p ps=50.52u w=50u l=0.7u
X457 a_33684_148611# ESD_RAIL ESD_RAIL VSS nfet_06v0 ad=13p pd=50.52u as=13p ps=50.52u w=50u l=0.7u
X458 a_33684_148611# ESD_RAIL ESD_RAIL VSS nfet_06v0 ad=22p pd=0.10088m as=13p ps=50.52u w=50u l=0.7u
D11 PAD_N ESD_RAIL diode_pd2nw_06v0 pj=51.8u area=22.5p
X459 a_33684_160275# a_33684_160275# VSS VSS nfet_06v0 ad=13p pd=50.52u as=13p ps=50.52u w=50u l=0.7u
X460 ESD_RAIL ESD_RAIL a_33684_148611# VSS nfet_06v0 ad=13p pd=50.52u as=13p ps=50.52u w=50u l=0.7u
X461 ESD_RAIL ESD_RAIL a_33684_148611# VSS nfet_06v0 ad=13p pd=50.52u as=13p ps=50.52u w=50u l=0.7u
X462 a_36789_117064# a_35813_117064# VSS VSS nfet_06v0 ad=1.3p pd=5.52u as=1.3p ps=5.52u w=5u l=0.7u
X463 a_33684_148611# ESD_RAIL ESD_RAIL VSS nfet_06v0 ad=13p pd=50.52u as=13p ps=50.52u w=50u l=0.7u
X464 VSS a_33684_160275# a_33684_160275# VSS nfet_06v0 ad=13p pd=50.52u as=13p ps=50.52u w=50u l=0.7u
X465 a_33684_160275# a_33684_160275# VSS VSS nfet_06v0 ad=13p pd=50.52u as=13p ps=50.52u w=50u l=0.7u
X466 a_33684_148611# ESD_RAIL ESD_RAIL VSS nfet_06v0 ad=13p pd=50.52u as=13p ps=50.52u w=50u l=0.7u
X467 ESD_RAIL a_34245_90628# VSS VSS nfet_06v0 ad=13p pd=50.52u as=13p ps=50.52u w=50u l=0.7u
X468 PAD_P CASCODE SUM_P_D_3 VSS nfet_06v0 ad=7.04p pd=32.88u as=7.04p ps=32.88u w=16u l=0.7u
X469 ESD_RAIL ESD_RAIL a_33684_148611# VSS nfet_06v0 ad=13p pd=50.52u as=13p ps=50.52u w=50u l=0.7u
D12 PAD_N ESD_RAIL diode_pd2nw_06v0 pj=51.8u area=22.5p
X470 MAIN_TAIL_1 MAIN_BIAS VSS VSS nfet_03v3 ad=8.8p pd=40.88u as=8.8p ps=40.88u w=20u l=1u
X471 VSS a_33684_160275# a_33684_160275# VSS nfet_06v0 ad=13p pd=50.52u as=13p ps=50.52u w=50u l=0.7u
X472 POST_TAIL_2 POST_BIAS VSS VSS nfet_03v3 ad=8.8p pd=40.88u as=8.8p ps=40.88u w=20u l=1u
X473 a_33684_148611# ESD_RAIL ESD_RAIL VSS nfet_06v0 ad=13p pd=50.52u as=13p ps=50.52u w=50u l=0.7u
X474 ESD_RAIL ESD_RAIL a_33684_148611# VSS nfet_06v0 ad=13p pd=50.52u as=13p ps=50.52u w=50u l=0.7u
X475 VSS a_33684_160275# a_33684_160275# VSS nfet_06v0 ad=13p pd=50.52u as=13p ps=50.52u w=50u l=0.7u
X476 SUM_P_D_0 MAIN_P MAIN_TAIL_0 VSS nfet_03v3 ad=8.8p pd=40.88u as=8.8p ps=40.88u w=20u l=0.28u
X477 a_33684_148611# ESD_RAIL ESD_RAIL VSS nfet_06v0 ad=13p pd=50.52u as=13p ps=50.52u w=50u l=0.7u
X478 a_33684_160275# a_33684_160275# VSS VSS nfet_06v0 ad=13p pd=50.52u as=13p ps=50.52u w=50u l=0.7u
X479 a_33684_160275# a_33684_160275# VSS VSS nfet_06v0 ad=13p pd=50.52u as=13p ps=50.52u w=50u l=0.7u
X480 a_33684_148611# a_33684_148611# a_33684_160275# VSS nfet_06v0 ad=13p pd=50.52u as=13p ps=50.52u w=50u l=0.7u
X481 ESD_RAIL ESD_RAIL a_33684_148611# VSS nfet_06v0 ad=13p pd=50.52u as=13p ps=50.52u w=50u l=0.7u
X482 TERM_N_R TERM_ENABLE_LOCAL TERM_VCM VSS nfet_03v3 ad=8.8p pd=40.88u as=8.8p ps=40.88u w=20u l=0.28u
X483 VSS a_33684_160275# a_33684_160275# VSS nfet_06v0 ad=13p pd=50.52u as=13p ps=50.52u w=50u l=0.7u
X484 a_33684_160275# a_33684_148611# a_33684_148611# VSS nfet_06v0 ad=13p pd=50.52u as=13p ps=50.52u w=50u l=0.7u
X485 a_33684_148611# ESD_RAIL ESD_RAIL VSS nfet_06v0 ad=13p pd=50.52u as=13p ps=50.52u w=50u l=0.7u
X486 TERM_BLEED_4 TERM_BLEED_5 VSS ppolyf_u_1k r_width=1u r_length=12.5u
X487 VSS a_33684_160275# a_33684_160275# VSS nfet_06v0 ad=13p pd=50.52u as=13p ps=50.52u w=50u l=0.7u
X488 a_33684_160275# a_33684_160275# VSS VSS nfet_06v0 ad=13p pd=50.52u as=13p ps=50.52u w=50u l=0.7u
X489 POST_TAIL_2 POST_BIAS VSS VSS nfet_03v3 ad=8.8p pd=40.88u as=8.8p ps=40.88u w=20u l=1u
X490 ESD_RAIL ESD_RAIL a_33684_148611# VSS nfet_06v0 ad=13p pd=50.52u as=13p ps=50.52u w=50u l=0.7u
X491 a_33684_148611# ESD_RAIL ESD_RAIL VSS nfet_06v0 ad=13p pd=50.52u as=13p ps=50.52u w=50u l=0.7u
X492 TMDS_TAIL_6 TMDS_BIAS VSS VSS nfet_03v3 ad=8.8p pd=40.88u as=8.8p ps=40.88u w=20u l=1u
X493 a_33684_148611# ESD_RAIL ESD_RAIL VSS nfet_06v0 ad=13p pd=50.52u as=13p ps=50.52u w=50u l=0.7u
X494 ESD_RAIL ESD_RAIL a_33684_148611# VSS nfet_06v0 ad=13p pd=50.52u as=13p ps=50.52u w=50u l=0.7u
X495 ESD_RAIL ESD_RAIL a_33684_148611# VSS nfet_06v0 ad=13p pd=50.52u as=13p ps=50.52u w=50u l=0.7u
X496 VSS a_33684_160275# a_33684_160275# VSS nfet_06v0 ad=13p pd=50.52u as=13p ps=50.52u w=50u l=0.7u
X497 a_33684_160275# a_33684_148611# a_33684_148611# VSS nfet_06v0 ad=13p pd=50.52u as=13p ps=50.52u w=50u l=0.7u
X498 a_33684_148611# ESD_RAIL ESD_RAIL VSS nfet_06v0 ad=13p pd=50.52u as=13p ps=50.52u w=50u l=0.7u
X499 a_33684_160275# a_33684_160275# VSS VSS nfet_06v0 ad=13p pd=50.52u as=13p ps=50.52u w=50u l=0.7u
X500 a_33684_148611# a_33684_148611# a_33684_160275# VSS nfet_06v0 ad=13p pd=50.52u as=13p ps=50.52u w=50u l=0.7u
X501 ESD_RAIL ESD_RAIL a_33684_148611# VSS nfet_06v0 ad=13p pd=50.52u as=13p ps=50.52u w=50u l=0.7u
X502 ESD_RAIL a_34245_90628# VSS VSS nfet_06v0 ad=13p pd=50.52u as=13p ps=50.52u w=50u l=0.7u
X503 PAD_P TERM_P_R VSS ppolyf_s r_width=1u r_length=1.8u
X504 a_33005_132385# a_45878_132665# ESD_RAIL ppolyf_u r_width=0.8u r_length=63.855u
X505 a_33684_160275# a_33684_160275# VSS VSS nfet_06v0 ad=13p pd=50.52u as=13p ps=50.52u w=50u l=0.7u
X506 ESD_RAIL ESD_RAIL a_33684_148611# VSS nfet_06v0 ad=13p pd=50.52u as=13p ps=50.52u w=50u l=0.7u
X507 VSS a_33684_160275# a_33684_160275# VSS nfet_06v0 ad=13p pd=50.52u as=13p ps=50.52u w=50u l=0.7u
X508 VSS a_33684_160275# a_33684_160275# VSS nfet_06v0 ad=13p pd=50.52u as=13p ps=50.52u w=50u l=0.7u
X509 PAD_N CASCODE SUM_N_D_0 VSS nfet_06v0 ad=7.04p pd=32.88u as=7.04p ps=32.88u w=16u l=0.7u
X510 a_33684_148611# ESD_RAIL ESD_RAIL VSS nfet_06v0 ad=13p pd=50.52u as=13p ps=50.52u w=50u l=0.7u
X511 a_33684_160275# a_33684_148611# a_33684_148611# VSS nfet_06v0 ad=13p pd=50.52u as=13p ps=50.52u w=50u l=0.7u
X512 a_33684_160275# a_33684_160275# VSS VSS nfet_06v0 ad=13p pd=50.52u as=13p ps=50.52u w=50u l=0.7u
X513 VSS a_36789_117064# a_34245_90628# VSS nfet_06v0 ad=2.2p pd=10.88u as=1.3p ps=5.52u w=5u l=0.7u
X514 a_34245_90628# a_36789_117064# ESD_RAIL ESD_RAIL pfet_06v0 ad=1.3p pd=5.52u as=1.3p ps=5.52u w=5u l=0.7u
X515 ESD_RAIL ESD_RAIL a_33684_148611# VSS nfet_06v0 ad=13p pd=50.52u as=13p ps=50.52u w=50u l=0.7u
X516 TERM_P_R TERM_ENABLE_LOCAL TERM_VCM VSS nfet_03v3 ad=8.8p pd=40.88u as=8.8p ps=40.88u w=20u l=0.28u
X517 a_33684_160275# a_33684_148611# a_33684_148611# VSS nfet_06v0 ad=13p pd=50.52u as=13p ps=50.52u w=50u l=0.7u
X518 a_33684_148611# ESD_RAIL ESD_RAIL VSS nfet_06v0 ad=13p pd=50.52u as=13p ps=50.52u w=50u l=0.7u
X519 VSS a_34245_90628# ESD_RAIL VSS nfet_06v0 ad=13p pd=50.52u as=13p ps=50.52u w=50u l=0.7u
X520 ESD_RAIL ESD_RAIL a_33684_148611# VSS nfet_06v0 ad=13p pd=50.52u as=13p ps=50.52u w=50u l=0.7u
X521 a_33684_148611# a_33684_148611# a_33684_160275# VSS nfet_06v0 ad=13p pd=50.52u as=13p ps=50.52u w=50u l=0.7u
X522 a_33684_160275# a_33684_148611# a_33684_148611# VSS nfet_06v0 ad=13p pd=50.52u as=13p ps=50.52u w=50u l=0.7u
X523 a_33684_160275# a_33684_148611# a_33684_148611# VSS nfet_06v0 ad=13p pd=50.52u as=13p ps=50.52u w=50u l=0.7u
X524 a_33684_148611# ESD_RAIL ESD_RAIL VSS nfet_06v0 ad=13p pd=50.52u as=13p ps=50.52u w=50u l=0.7u
X525 ESD_RAIL ESD_RAIL a_33684_148611# VSS nfet_06v0 ad=13p pd=50.52u as=13p ps=50.52u w=50u l=0.7u
X526 a_33684_148611# ESD_RAIL ESD_RAIL VSS nfet_06v0 ad=13p pd=50.52u as=13p ps=50.52u w=50u l=0.7u
X527 POST_TAIL_1 POST_BIAS VSS VSS nfet_03v3 ad=8.8p pd=40.88u as=8.8p ps=40.88u w=20u l=1u
X528 a_33684_148611# a_33684_148611# a_33684_160275# VSS nfet_06v0 ad=13p pd=50.52u as=13p ps=50.52u w=50u l=0.7u
X529 VSS a_34245_90628# ESD_RAIL VSS nfet_06v0 ad=13p pd=50.52u as=13p ps=50.52u w=50u l=0.7u
X530 ESD_RAIL ESD_RAIL a_33684_148611# VSS nfet_06v0 ad=13p pd=50.52u as=13p ps=50.52u w=50u l=0.7u
X531 a_33684_160275# a_33684_148611# a_33684_148611# VSS nfet_06v0 ad=13p pd=50.52u as=13p ps=50.52u w=50u l=0.7u
X532 a_33684_160275# a_33684_148611# a_33684_148611# VSS nfet_06v0 ad=13p pd=50.52u as=13p ps=50.52u w=50u l=0.7u
X533 a_33684_148611# ESD_RAIL ESD_RAIL VSS nfet_06v0 ad=13p pd=50.52u as=13p ps=50.52u w=50u l=0.7u
X534 a_33684_148611# ESD_RAIL ESD_RAIL VSS nfet_06v0 ad=13p pd=50.52u as=13p ps=50.52u w=50u l=0.7u
X535 a_33684_160275# a_33684_148611# a_33684_148611# VSS nfet_06v0 ad=13p pd=50.52u as=13p ps=50.52u w=50u l=0.7u
X536 MAIN_TAIL_7 MAIN_BIAS VSS VSS nfet_03v3 ad=8.8p pd=40.88u as=8.8p ps=40.88u w=20u l=1u
X537 PAD_P CASCODE SUM_P_D_3 VSS nfet_06v0 ad=7.04p pd=32.88u as=7.04p ps=32.88u w=16u l=0.7u
X538 a_33684_148611# a_33684_148611# a_33684_160275# VSS nfet_06v0 ad=13p pd=50.52u as=13p ps=50.52u w=50u l=0.7u
X539 a_33684_160275# a_33684_148611# a_33684_148611# VSS nfet_06v0 ad=13p pd=50.52u as=13p ps=50.52u w=50u l=0.7u
X540 ESD_RAIL ESD_RAIL a_33684_148611# VSS nfet_06v0 ad=13p pd=50.52u as=13p ps=50.52u w=50u l=0.7u
X541 a_33684_148611# a_33684_148611# a_33684_160275# VSS nfet_06v0 ad=13p pd=50.52u as=13p ps=50.52u w=50u l=0.7u
X542 TMDS_TAIL_7 TMDS_BIAS VSS VSS nfet_03v3 ad=8.8p pd=40.88u as=8.8p ps=40.88u w=20u l=1u
X543 VSS a_34245_90628# ESD_RAIL VSS nfet_06v0 ad=13p pd=50.52u as=13p ps=50.52u w=50u l=0.7u
X544 SUM_N_D_2 POST_N POST_TAIL_2 VSS nfet_03v3 ad=8.8p pd=40.88u as=8.8p ps=40.88u w=20u l=0.28u
X545 a_33684_160275# a_33684_148611# a_33684_148611# VSS nfet_06v0 ad=13p pd=50.52u as=13p ps=50.52u w=50u l=0.7u
X546 a_33684_160275# a_33684_148611# a_33684_148611# VSS nfet_06v0 ad=13p pd=50.52u as=13p ps=50.52u w=50u l=0.7u
X547 a_33684_148611# a_33684_148611# a_33684_160275# VSS nfet_06v0 ad=13p pd=50.52u as=13p ps=50.52u w=50u l=0.7u
X548 a_33684_148611# ESD_RAIL ESD_RAIL VSS nfet_06v0 ad=13p pd=50.52u as=13p ps=50.52u w=50u l=0.7u
X549 a_33684_148611# a_33684_148611# a_33684_160275# VSS nfet_06v0 ad=13p pd=50.52u as=13p ps=50.52u w=50u l=0.7u
D13 PAD_N ESD_RAIL diode_pd2nw_06v0 pj=51.8u area=22.5p
X550 ESD_RAIL ESD_RAIL a_33684_148611# VSS nfet_06v0 ad=13p pd=50.52u as=13p ps=50.52u w=50u l=0.7u
X551 VSS a_34245_90628# ESD_RAIL VSS nfet_06v0 ad=13p pd=50.52u as=13p ps=50.52u w=50u l=0.7u
X552 MAIN_TAIL_5 MAIN_BIAS VSS VSS nfet_03v3 ad=8.8p pd=40.88u as=8.8p ps=40.88u w=20u l=1u
X553 a_33684_160275# a_33684_148611# a_33684_148611# VSS nfet_06v0 ad=13p pd=50.52u as=13p ps=50.52u w=50u l=0.7u
X554 a_33684_160275# a_33684_148611# a_33684_148611# VSS nfet_06v0 ad=13p pd=50.52u as=13p ps=50.52u w=50u l=0.7u
X555 a_33684_148611# ESD_RAIL ESD_RAIL VSS nfet_06v0 ad=13p pd=50.52u as=13p ps=50.52u w=50u l=0.7u
X556 a_33005_133505# a_45878_133785# ESD_RAIL ppolyf_u r_width=0.8u r_length=63.855u
X557 ESD_RAIL ESD_RAIL a_33684_148611# VSS nfet_06v0 ad=13p pd=50.52u as=13p ps=50.52u w=50u l=0.7u
X558 DETECT_BLEED_2 DETECT_BLEED_3 VSS ppolyf_u_1k r_width=1u r_length=12.5u
X559 a_33684_148611# a_33684_148611# a_33684_160275# VSS nfet_06v0 ad=13p pd=50.52u as=13p ps=50.52u w=50u l=0.7u
X560 a_33684_148611# ESD_RAIL ESD_RAIL VSS nfet_06v0 ad=13p pd=50.52u as=13p ps=50.52u w=50u l=0.7u
X561 POST_TAIL_0 POST_BIAS VSS VSS nfet_03v3 ad=8.8p pd=40.88u as=8.8p ps=40.88u w=20u l=1u
X562 VSS a_33684_160275# a_33684_160275# VSS nfet_06v0 ad=13p pd=50.52u as=13p ps=50.52u w=50u l=0.7u
X563 ESD_RAIL ESD_RAIL a_33684_148611# VSS nfet_06v0 ad=13p pd=50.52u as=13p ps=50.52u w=50u l=0.7u
X564 a_33684_148611# a_33684_148611# a_33684_160275# VSS nfet_06v0 ad=13p pd=50.52u as=13p ps=50.52u w=50u l=0.7u
X565 ESD_RAIL a_34245_90628# VSS VSS nfet_06v0 ad=13p pd=50.52u as=13p ps=50.52u w=50u l=0.7u
X566 a_34245_90628# a_36789_117064# VSS VSS nfet_06v0 ad=1.3p pd=5.52u as=1.3p ps=5.52u w=5u l=0.7u
X567 a_33684_160275# a_33684_148611# a_33684_148611# VSS nfet_06v0 ad=13p pd=50.52u as=13p ps=50.52u w=50u l=0.7u
X568 a_33684_160275# a_33684_148611# a_33684_148611# VSS nfet_06v0 ad=13p pd=50.52u as=13p ps=50.52u w=50u l=0.7u
X569 VSS a_33684_160275# a_33684_160275# VSS nfet_06v0 ad=13p pd=50.52u as=13p ps=50.52u w=50u l=0.7u
X570 a_33684_148611# a_33684_148611# a_33684_160275# VSS nfet_06v0 ad=13p pd=50.52u as=13p ps=50.52u w=50u l=0.7u
X571 a_33684_148611# a_33684_148611# a_33684_160275# VSS nfet_06v0 ad=13p pd=50.52u as=13p ps=50.52u w=50u l=0.7u
X572 ESD_RAIL a_34245_90628# VSS VSS nfet_06v0 ad=13p pd=50.52u as=13p ps=50.52u w=50u l=0.7u
X573 DETECT_N_I DETECT_PBIAS VDD VDD pfet_03v3 ad=1.76p pd=8.88u as=1.76p ps=8.88u w=4u l=2u
X574 a_33684_160275# a_33684_148611# a_33684_148611# VSS nfet_06v0 ad=13p pd=50.52u as=13p ps=50.52u w=50u l=0.7u
X575 ESD_RAIL a_36789_117064# a_34245_90628# ESD_RAIL pfet_06v0 ad=1.3p pd=5.52u as=1.3p ps=5.52u w=5u l=0.7u
X576 VSS a_33684_160275# a_33684_160275# VSS nfet_06v0 ad=13p pd=50.52u as=13p ps=50.52u w=50u l=0.7u
X577 a_33684_160275# a_33684_148611# a_33684_148611# VSS nfet_06v0 ad=13p pd=50.52u as=13p ps=50.52u w=50u l=0.7u
X578 a_33684_160275# a_33684_160275# VSS VSS nfet_06v0 ad=13p pd=50.52u as=13p ps=50.52u w=50u l=0.7u
X579 a_33684_148611# a_33684_148611# a_33684_160275# VSS nfet_06v0 ad=13p pd=50.52u as=13p ps=50.52u w=50u l=0.7u
X580 a_33684_160275# a_33684_148611# a_33684_148611# VSS nfet_06v0 ad=13p pd=50.52u as=13p ps=50.52u w=50u l=0.7u
X581 SUM_P_D_6 TMDS_P TMDS_TAIL_6 VSS nfet_03v3 ad=8.8p pd=40.88u as=8.8p ps=40.88u w=20u l=0.28u
X582 SUM_N_D_5 POST_N POST_TAIL_5 VSS nfet_03v3 ad=8.8p pd=40.88u as=8.8p ps=40.88u w=20u l=0.28u
X583 a_33684_148611# a_33684_148611# a_33684_160275# VSS nfet_06v0 ad=13p pd=50.52u as=13p ps=50.52u w=50u l=0.7u
X584 a_33684_160275# a_33684_160275# VSS VSS nfet_06v0 ad=13p pd=50.52u as=13p ps=50.52u w=50u l=0.7u
X585 a_33684_160275# a_33684_148611# a_33684_148611# VSS nfet_06v0 ad=13p pd=50.52u as=13p ps=50.52u w=50u l=0.7u
X586 a_33684_148611# a_33684_148611# a_33684_160275# VSS nfet_06v0 ad=13p pd=50.52u as=13p ps=50.52u w=50u l=0.7u
X587 a_34245_90628# VSS VSS ppolyf_u_1k_6p0 r_width=1u r_length=99.24u
X588 MAIN_TAIL_2 MAIN_BIAS VSS VSS nfet_03v3 ad=8.8p pd=40.88u as=8.8p ps=40.88u w=20u l=1u
X589 a_33684_160275# a_33684_160275# VSS VSS nfet_06v0 ad=13p pd=50.52u as=13p ps=50.52u w=50u l=0.7u
X590 a_33684_148611# a_33684_148611# a_33684_160275# VSS nfet_06v0 ad=13p pd=50.52u as=13p ps=50.52u w=50u l=0.7u
X591 ESD_RAIL a_34245_90628# VSS VSS nfet_06v0 ad=13p pd=50.52u as=13p ps=50.52u w=50u l=0.7u
X592 a_36789_117064# a_35813_117064# VSS VSS nfet_06v0 ad=1.3p pd=5.52u as=1.3p ps=5.52u w=5u l=0.7u
X593 a_33684_160275# a_33684_148611# a_33684_148611# VSS nfet_06v0 ad=13p pd=50.52u as=13p ps=50.52u w=50u l=0.7u
X594 PAD_P CASCODE SUM_P_D_0 VSS nfet_06v0 ad=7.04p pd=32.88u as=7.04p ps=32.88u w=16u l=0.7u
X595 TERM_N_R TERM_ENABLE_LOCAL TERM_VCM VSS nfet_03v3 ad=8.8p pd=40.88u as=8.8p ps=40.88u w=20u l=0.28u
X596 DETECT_BLEED_6 VSS VSS ppolyf_u_1k r_width=1u r_length=12.5u
X597 a_33684_148611# a_33684_148611# a_33684_160275# VSS nfet_06v0 ad=13p pd=50.52u as=13p ps=50.52u w=50u l=0.7u
X598 a_33684_160275# a_33684_160275# VSS VSS nfet_06v0 ad=13p pd=50.52u as=13p ps=50.52u w=50u l=0.7u
X599 VSS a_33684_160275# a_33684_160275# VSS nfet_06v0 ad=13p pd=50.52u as=13p ps=50.52u w=50u l=0.7u
X600 a_33684_148611# ESD_RAIL ESD_RAIL VSS nfet_06v0 ad=13p pd=50.52u as=13p ps=50.52u w=50u l=0.7u
X601 TERM_P_R TERM_ENABLE_LOCAL TERM_VCM VSS nfet_03v3 ad=8.8p pd=40.88u as=8.8p ps=40.88u w=20u l=0.28u
X602 a_33684_148611# a_33684_148611# a_33684_160275# VSS nfet_06v0 ad=13p pd=50.52u as=13p ps=50.52u w=50u l=0.7u
X603 PAD_P CASCODE SUM_P_D_2 VSS nfet_06v0 ad=7.04p pd=32.88u as=7.04p ps=32.88u w=16u l=0.7u
X604 a_33684_160275# a_33684_148611# a_33684_148611# VSS nfet_06v0 ad=13p pd=50.52u as=13p ps=50.52u w=50u l=0.7u
D14 VSS ESD_RAIL diode_nd2ps_06v0 pj=82u area=40p
X605 VSS a_33684_160275# a_33684_160275# VSS nfet_06v0 ad=13p pd=50.52u as=13p ps=50.52u w=50u l=0.7u
X606 PAD_P CASCODE SUM_P_D_1 VSS nfet_06v0 ad=7.04p pd=32.88u as=7.04p ps=32.88u w=16u l=0.7u
X607 a_33684_148611# ESD_RAIL ESD_RAIL VSS nfet_06v0 ad=13p pd=50.52u as=13p ps=50.52u w=50u l=0.7u
X608 POST_TAIL_7 POST_BIAS VSS VSS nfet_03v3 ad=8.8p pd=40.88u as=8.8p ps=40.88u w=20u l=1u
X609 VSS a_33684_160275# a_33684_160275# VSS nfet_06v0 ad=13p pd=50.52u as=13p ps=50.52u w=50u l=0.7u
X610 a_33684_148611# a_33684_148611# a_33684_160275# VSS nfet_06v0 ad=13p pd=50.52u as=13p ps=50.52u w=50u l=0.7u
X611 VSS a_34245_90628# ESD_RAIL VSS nfet_06v0 ad=13p pd=50.52u as=13p ps=50.52u w=50u l=0.7u
X612 VSS a_34245_90628# ESD_RAIL VSS nfet_06v0 ad=13p pd=50.52u as=13p ps=50.52u w=50u l=0.7u
X613 MAIN_TAIL_3 MAIN_BIAS VSS VSS nfet_03v3 ad=8.8p pd=40.88u as=8.8p ps=40.88u w=20u l=1u
X614 a_33684_160275# a_33684_148611# a_33684_148611# VSS nfet_06v0 ad=13p pd=50.52u as=13p ps=50.52u w=50u l=0.7u
X615 VSS a_34245_90628# ESD_RAIL VSS nfet_06v0 ad=13p pd=50.52u as=13p ps=50.52u w=50u l=0.7u
X616 POST_TAIL_5 POST_BIAS VSS VSS nfet_03v3 ad=8.8p pd=40.88u as=8.8p ps=40.88u w=20u l=1u
X617 VSS a_33684_160275# a_33684_160275# VSS nfet_06v0 ad=13p pd=50.52u as=13p ps=50.52u w=50u l=0.7u
X618 a_33684_148611# ESD_RAIL ESD_RAIL VSS nfet_06v0 ad=13p pd=50.52u as=13p ps=50.52u w=50u l=0.7u
X619 ESD_RAIL ESD_RAIL a_33684_148611# VSS nfet_06v0 ad=13p pd=50.52u as=13p ps=50.52u w=50u l=0.7u
X620 a_33684_148611# a_33684_148611# a_33684_160275# VSS nfet_06v0 ad=13p pd=50.52u as=13p ps=50.52u w=50u l=0.7u
X621 a_33684_160275# a_33684_148611# a_33684_148611# VSS nfet_06v0 ad=13p pd=50.52u as=13p ps=50.52u w=50u l=0.7u
X622 VSS a_34245_90628# ESD_RAIL VSS nfet_06v0 ad=13p pd=50.52u as=13p ps=50.52u w=50u l=0.7u
X623 a_33684_160275# a_33684_148611# a_33684_148611# VSS nfet_06v0 ad=13p pd=50.52u as=13p ps=50.52u w=50u l=0.7u
X624 a_33684_160275# a_33684_160275# VSS VSS nfet_06v0 ad=13p pd=50.52u as=13p ps=50.52u w=50u l=0.7u
X625 MAIN_TAIL_3 MAIN_BIAS VSS VSS nfet_03v3 ad=8.8p pd=40.88u as=8.8p ps=40.88u w=20u l=1u
X626 a_33684_160275# a_33684_160275# VSS VSS nfet_06v0 ad=13p pd=50.52u as=13p ps=50.52u w=50u l=0.7u
X627 ESD_RAIL ESD_RAIL a_33684_148611# VSS nfet_06v0 ad=13p pd=50.52u as=13p ps=50.52u w=50u l=0.7u
X628 a_33684_160275# a_33684_148611# a_33684_148611# VSS nfet_06v0 ad=13p pd=50.52u as=13p ps=50.52u w=50u l=0.7u
X629 ESD_RAIL a_34245_90628# VSS VSS nfet_06v0 ad=22p pd=0.10088m as=13p ps=50.52u w=50u l=0.7u
X630 a_33005_133505# a_45878_133225# ESD_RAIL ppolyf_u r_width=0.8u r_length=63.855u
X631 a_33684_160275# a_33684_160275# VSS VSS nfet_06v0 ad=13p pd=50.52u as=13p ps=50.52u w=50u l=0.7u
X632 ESD_RAIL ESD_RAIL a_33684_148611# VSS nfet_06v0 ad=13p pd=50.52u as=13p ps=50.52u w=50u l=0.7u
X633 a_33684_160275# a_33684_160275# VSS VSS nfet_06v0 ad=13p pd=50.52u as=13p ps=50.52u w=50u l=0.7u
X634 VSS a_34245_90628# ESD_RAIL VSS nfet_06v0 ad=13p pd=50.52u as=13p ps=50.52u w=50u l=0.7u
X635 SUM_P_D_4 TMDS_P TMDS_TAIL_4 VSS nfet_03v3 ad=8.8p pd=40.88u as=8.8p ps=40.88u w=20u l=0.28u
X636 a_33684_160275# a_33684_148611# a_33684_148611# VSS nfet_06v0 ad=13p pd=50.52u as=13p ps=50.52u w=50u l=0.7u
X637 PAD_P CASCODE SUM_P_D_6 VSS nfet_06v0 ad=7.04p pd=32.88u as=7.04p ps=32.88u w=16u l=0.7u
X638 VSS a_33684_160275# a_33684_160275# VSS nfet_06v0 ad=13p pd=50.52u as=13p ps=50.52u w=50u l=0.7u
X639 a_33684_160275# a_33684_160275# VSS VSS nfet_06v0 ad=13p pd=50.52u as=13p ps=50.52u w=50u l=0.7u
X640 ESD_RAIL ESD_RAIL a_33684_148611# VSS nfet_06v0 ad=13p pd=50.52u as=13p ps=50.52u w=50u l=0.7u
X641 a_33684_148611# ESD_RAIL ESD_RAIL VSS nfet_06v0 ad=13p pd=50.52u as=13p ps=50.52u w=50u l=0.7u
X642 PAD_P CASCODE SUM_P_D_7 VSS nfet_06v0 ad=7.04p pd=32.88u as=7.04p ps=32.88u w=16u l=0.7u
X643 VSS a_33684_160275# a_33684_160275# VSS nfet_06v0 ad=13p pd=50.52u as=13p ps=50.52u w=50u l=0.7u
X644 VSS a_33684_160275# a_33684_160275# VSS nfet_06v0 ad=13p pd=50.52u as=13p ps=50.52u w=50u l=0.7u
X645 a_33684_160275# a_33684_160275# VSS VSS nfet_06v0 ad=13p pd=50.52u as=13p ps=50.52u w=50u l=0.7u
X646 a_33684_148611# ESD_RAIL ESD_RAIL VSS nfet_06v0 ad=13p pd=50.52u as=13p ps=50.52u w=50u l=0.7u
X647 a_33684_148611# ESD_RAIL ESD_RAIL VSS nfet_06v0 ad=13p pd=50.52u as=13p ps=50.52u w=50u l=0.7u
X648 TMDS_TAIL_0 TMDS_BIAS VSS VSS nfet_03v3 ad=8.8p pd=40.88u as=8.8p ps=40.88u w=20u l=1u
X649 VSS a_33684_160275# a_33684_160275# VSS nfet_06v0 ad=13p pd=50.52u as=13p ps=50.52u w=50u l=0.7u
X650 SUM_N_D_6 MAIN_N MAIN_TAIL_6 VSS nfet_03v3 ad=8.8p pd=40.88u as=8.8p ps=40.88u w=20u l=0.28u
D15 PAD_P ESD_RAIL diode_pd2nw_06v0 pj=51.8u area=22.5p
X651 a_33005_131545# VSS cap_mim_2f0_m4m5_noshield c_width=31.6u c_length=31.6u
X652 VSS a_33684_160275# a_33684_160275# VSS nfet_06v0 ad=13p pd=50.52u as=13p ps=50.52u w=50u l=0.7u
X653 a_33684_148611# a_33684_148611# a_33684_160275# VSS nfet_06v0 ad=13p pd=50.52u as=13p ps=50.52u w=50u l=0.7u
X654 MAIN_TAIL_2 MAIN_BIAS VSS VSS nfet_03v3 ad=8.8p pd=40.88u as=8.8p ps=40.88u w=20u l=1u
X655 VSS a_33684_160275# a_33684_160275# VSS nfet_06v0 ad=13p pd=50.52u as=13p ps=50.52u w=50u l=0.7u
X656 a_33684_160275# a_33684_160275# VSS VSS nfet_06v0 ad=13p pd=50.52u as=13p ps=50.52u w=50u l=0.7u
X657 VSS a_33684_160275# a_33684_160275# VSS nfet_06v0 ad=13p pd=50.52u as=13p ps=50.52u w=50u l=0.7u
X658 a_33684_148611# ESD_RAIL ESD_RAIL VSS nfet_06v0 ad=13p pd=50.52u as=13p ps=50.52u w=50u l=0.7u
X659 a_33684_160275# a_33684_148611# a_33684_148611# VSS nfet_06v0 ad=13p pd=50.52u as=13p ps=50.52u w=50u l=0.7u
X660 MAIN_TAIL_0 MAIN_BIAS VSS VSS nfet_03v3 ad=8.8p pd=40.88u as=8.8p ps=40.88u w=20u l=1u
X661 a_33684_148611# a_33684_148611# a_33684_160275# VSS nfet_06v0 ad=13p pd=50.52u as=13p ps=50.52u w=50u l=0.7u
X662 SUM_P_D_2 TMDS_P TMDS_TAIL_2 VSS nfet_03v3 ad=8.8p pd=40.88u as=8.8p ps=40.88u w=20u l=0.28u
X663 ESD_RAIL ESD_RAIL a_33684_148611# VSS nfet_06v0 ad=13p pd=50.52u as=13p ps=50.52u w=50u l=0.7u
X664 a_33684_160275# a_33684_148611# a_33684_148611# VSS nfet_06v0 ad=13p pd=50.52u as=13p ps=50.52u w=50u l=0.7u
X665 a_33684_160275# a_33684_148611# a_33684_148611# VSS nfet_06v0 ad=13p pd=50.52u as=13p ps=50.52u w=50u l=0.7u
X666 ESD_RAIL ESD_RAIL a_33684_148611# VSS nfet_06v0 ad=13p pd=50.52u as=13p ps=50.52u w=50u l=0.7u
X667 a_33684_148611# a_33684_148611# a_33684_160275# VSS nfet_06v0 ad=13p pd=50.52u as=13p ps=50.52u w=50u l=0.7u
X668 ESD_RAIL a_34245_90628# VSS VSS nfet_06v0 ad=13p pd=50.52u as=13p ps=50.52u w=50u l=0.7u
X669 SUM_N_D_3 MAIN_N MAIN_TAIL_3 VSS nfet_03v3 ad=8.8p pd=40.88u as=8.8p ps=40.88u w=20u l=0.28u
X670 a_33684_160275# a_33684_160275# VSS VSS nfet_06v0 ad=13p pd=50.52u as=13p ps=50.52u w=50u l=0.7u
X671 PAD_P CASCODE SUM_P_D_5 VSS nfet_06v0 ad=7.04p pd=32.88u as=7.04p ps=32.88u w=16u l=0.7u
X672 VSS a_33684_160275# a_33684_160275# VSS nfet_06v0 ad=13p pd=50.52u as=13p ps=50.52u w=50u l=0.7u
X673 ESD_RAIL ESD_RAIL a_33684_148611# VSS nfet_06v0 ad=13p pd=50.52u as=13p ps=50.52u w=50u l=0.7u
X674 ESD_RAIL ESD_RAIL a_33684_148611# VSS nfet_06v0 ad=13p pd=50.52u as=13p ps=50.52u w=50u l=0.7u
X675 ESD_RAIL a_45878_134345# ESD_RAIL ppolyf_u r_width=0.8u r_length=63.855u
X676 a_33684_160275# a_33684_148611# a_33684_148611# VSS nfet_06v0 ad=13p pd=50.52u as=13p ps=50.52u w=50u l=0.7u
X677 ESD_RAIL a_34245_90628# VSS VSS nfet_06v0 ad=13p pd=50.52u as=13p ps=50.52u w=50u l=0.7u
X678 ESD_RAIL ESD_RAIL a_33684_148611# VSS nfet_06v0 ad=13p pd=50.52u as=13p ps=50.52u w=50u l=0.7u
X679 a_33684_148611# ESD_RAIL ESD_RAIL VSS nfet_06v0 ad=13p pd=50.52u as=13p ps=50.52u w=50u l=0.7u
X680 a_33684_148611# a_33684_148611# a_33684_160275# VSS nfet_06v0 ad=13p pd=50.52u as=13p ps=50.52u w=50u l=0.7u
X681 a_33684_148611# a_33684_148611# a_33684_160275# VSS nfet_06v0 ad=13p pd=50.52u as=13p ps=50.52u w=50u l=0.7u
X682 a_33684_160275# a_33684_148611# a_33684_148611# VSS nfet_06v0 ad=13p pd=50.52u as=13p ps=50.52u w=50u l=0.7u
X683 SUM_P_D_7 POST_P POST_TAIL_7 VSS nfet_03v3 ad=8.8p pd=40.88u as=8.8p ps=40.88u w=20u l=0.28u
X684 VSS a_33684_160275# a_33684_160275# VSS nfet_06v0 ad=13p pd=50.52u as=13p ps=50.52u w=50u l=0.7u
X685 a_33684_160275# a_33684_148611# a_33684_148611# VSS nfet_06v0 ad=13p pd=50.52u as=13p ps=50.52u w=50u l=0.7u
X686 a_33684_148611# ESD_RAIL ESD_RAIL VSS nfet_06v0 ad=13p pd=50.52u as=13p ps=50.52u w=50u l=0.7u
X687 a_33684_160275# a_33684_160275# VSS VSS nfet_06v0 ad=13p pd=50.52u as=13p ps=50.52u w=50u l=0.7u
X688 a_33684_148611# ESD_RAIL ESD_RAIL VSS nfet_06v0 ad=13p pd=50.52u as=13p ps=50.52u w=50u l=0.7u
X689 ESD_RAIL ESD_RAIL a_33684_148611# VSS nfet_06v0 ad=13p pd=50.52u as=13p ps=50.52u w=50u l=0.7u
X690 ESD_RAIL a_34245_90628# VSS VSS nfet_06v0 ad=13p pd=50.52u as=13p ps=50.52u w=50u l=0.7u
X691 a_33684_148611# ESD_RAIL ESD_RAIL VSS nfet_06v0 ad=13p pd=50.52u as=13p ps=50.52u w=50u l=0.7u
X692 a_33684_148611# a_33684_148611# a_33684_160275# VSS nfet_06v0 ad=13p pd=50.52u as=22p ps=0.10088m w=50u l=0.7u
X693 a_33684_148611# a_33684_148611# a_33684_160275# VSS nfet_06v0 ad=13p pd=50.52u as=13p ps=50.52u w=50u l=0.7u
X694 a_33684_160275# a_33684_148611# a_33684_148611# VSS nfet_06v0 ad=13p pd=50.52u as=13p ps=50.52u w=50u l=0.7u
X695 VSS a_34245_90628# ESD_RAIL VSS nfet_06v0 ad=13p pd=50.52u as=13p ps=50.52u w=50u l=0.7u
X696 a_33684_148611# ESD_RAIL ESD_RAIL VSS nfet_06v0 ad=13p pd=50.52u as=13p ps=50.52u w=50u l=0.7u
X697 a_33684_148611# ESD_RAIL ESD_RAIL VSS nfet_06v0 ad=13p pd=50.52u as=13p ps=50.52u w=50u l=0.7u
X698 ESD_RAIL ESD_RAIL a_33684_148611# VSS nfet_06v0 ad=13p pd=50.52u as=13p ps=50.52u w=50u l=0.7u
X699 PAD_N CASCODE SUM_N_D_5 VSS nfet_06v0 ad=7.04p pd=32.88u as=7.04p ps=32.88u w=16u l=0.7u
X700 a_33684_148611# ESD_RAIL ESD_RAIL VSS nfet_06v0 ad=13p pd=50.52u as=13p ps=50.52u w=50u l=0.7u
X701 a_33684_160275# a_33684_148611# a_33684_148611# VSS nfet_06v0 ad=13p pd=50.52u as=13p ps=50.52u w=50u l=0.7u
X702 a_33684_148611# a_33684_148611# a_33684_160275# VSS nfet_06v0 ad=13p pd=50.52u as=13p ps=50.52u w=50u l=0.7u
X703 VSS a_34245_90628# ESD_RAIL VSS nfet_06v0 ad=13p pd=50.52u as=22p ps=0.10088m w=50u l=0.7u
X704 TERM_BLEED_5 TERM_BLEED_6 VSS ppolyf_u_1k r_width=1u r_length=12.5u
X705 a_33684_148611# a_33684_148611# a_33684_160275# VSS nfet_06v0 ad=13p pd=50.52u as=13p ps=50.52u w=50u l=0.7u
X706 SUM_N_D_1 MAIN_N MAIN_TAIL_1 VSS nfet_03v3 ad=8.8p pd=40.88u as=8.8p ps=40.88u w=20u l=0.28u
X707 a_33684_160275# a_33684_148611# a_33684_148611# VSS nfet_06v0 ad=13p pd=50.52u as=13p ps=50.52u w=50u l=0.7u
X708 a_33684_160275# a_33684_148611# a_33684_148611# VSS nfet_06v0 ad=13p pd=50.52u as=13p ps=50.52u w=50u l=0.7u
X709 VSS a_34245_90628# ESD_RAIL VSS nfet_06v0 ad=13p pd=50.52u as=13p ps=50.52u w=50u l=0.7u
X710 a_33684_148611# a_33684_148611# a_33684_160275# VSS nfet_06v0 ad=13p pd=50.52u as=13p ps=50.52u w=50u l=0.7u
X711 a_33684_148611# a_33684_148611# a_33684_160275# VSS nfet_06v0 ad=13p pd=50.52u as=13p ps=50.52u w=50u l=0.7u
X712 ESD_RAIL a_34245_90628# VSS VSS nfet_06v0 ad=13p pd=50.52u as=13p ps=50.52u w=50u l=0.7u
X713 ESD_RAIL ESD_RAIL a_33684_148611# VSS nfet_06v0 ad=13p pd=50.52u as=13p ps=50.52u w=50u l=0.7u
X714 POST_TAIL_3 POST_BIAS VSS VSS nfet_03v3 ad=8.8p pd=40.88u as=8.8p ps=40.88u w=20u l=1u
X715 a_33684_148611# ESD_RAIL ESD_RAIL VSS nfet_06v0 ad=13p pd=50.52u as=13p ps=50.52u w=50u l=0.7u
X716 a_33684_148611# a_33684_148611# a_33684_160275# VSS nfet_06v0 ad=13p pd=50.52u as=13p ps=50.52u w=50u l=0.7u
X717 a_33684_160275# a_33684_148611# a_33684_148611# VSS nfet_06v0 ad=13p pd=50.52u as=13p ps=50.52u w=50u l=0.7u
X718 a_33684_148611# a_33684_148611# a_33684_160275# VSS nfet_06v0 ad=13p pd=50.52u as=13p ps=50.52u w=50u l=0.7u
X719 a_33684_160275# a_33684_160275# VSS VSS nfet_06v0 ad=13p pd=50.52u as=13p ps=50.52u w=50u l=0.7u
X720 a_33684_160275# a_33684_148611# a_33684_148611# VSS nfet_06v0 ad=13p pd=50.52u as=13p ps=50.52u w=50u l=0.7u
X721 VSS a_33684_160275# a_33684_160275# VSS nfet_06v0 ad=13p pd=50.52u as=13p ps=50.52u w=50u l=0.7u
X722 a_33684_160275# a_33684_148611# a_33684_148611# VSS nfet_06v0 ad=13p pd=50.52u as=13p ps=50.52u w=50u l=0.7u
X723 a_33684_148611# ESD_RAIL ESD_RAIL VSS nfet_06v0 ad=13p pd=50.52u as=13p ps=50.52u w=50u l=0.7u
X724 TERM_P_R TERM_ENABLE_LOCAL TERM_VCM VSS nfet_03v3 ad=8.8p pd=40.88u as=8.8p ps=40.88u w=20u l=0.28u
X725 ESD_RAIL ESD_RAIL a_33684_148611# VSS nfet_06v0 ad=13p pd=50.52u as=13p ps=50.52u w=50u l=0.7u
X726 a_33684_148611# a_33684_148611# a_33684_160275# VSS nfet_06v0 ad=13p pd=50.52u as=13p ps=50.52u w=50u l=0.7u
X727 a_33684_160275# a_33684_148611# a_33684_148611# VSS nfet_06v0 ad=13p pd=50.52u as=13p ps=50.52u w=50u l=0.7u
X728 a_33684_148611# a_33684_148611# a_33684_160275# VSS nfet_06v0 ad=13p pd=50.52u as=13p ps=50.52u w=50u l=0.7u
X729 POST_TAIL_0 POST_BIAS VSS VSS nfet_03v3 ad=8.8p pd=40.88u as=8.8p ps=40.88u w=20u l=1u
X730 a_33684_148611# a_33684_148611# a_33684_160275# VSS nfet_06v0 ad=13p pd=50.52u as=13p ps=50.52u w=50u l=0.7u
X731 a_33684_160275# a_33684_148611# a_33684_148611# VSS nfet_06v0 ad=13p pd=50.52u as=13p ps=50.52u w=50u l=0.7u
X732 TERM_BLEED_3 TERM_BLEED_4 VSS ppolyf_u_1k r_width=1u r_length=12.5u
X733 MAIN_TAIL_6 MAIN_BIAS VSS VSS nfet_03v3 ad=8.8p pd=40.88u as=8.8p ps=40.88u w=20u l=1u
X734 a_33684_160275# a_33684_148611# a_33684_148611# VSS nfet_06v0 ad=13p pd=50.52u as=13p ps=50.52u w=50u l=0.7u
X735 a_33684_148611# a_33684_148611# a_33684_160275# VSS nfet_06v0 ad=13p pd=50.52u as=13p ps=50.52u w=50u l=0.7u
X736 VSS a_33684_160275# a_33684_160275# VSS nfet_06v0 ad=13p pd=50.52u as=13p ps=50.52u w=50u l=0.7u
X737 a_33684_148611# a_33684_148611# a_33684_160275# VSS nfet_06v0 ad=13p pd=50.52u as=13p ps=50.52u w=50u l=0.7u
X738 TMDS_TAIL_6 TMDS_BIAS VSS VSS nfet_03v3 ad=8.8p pd=40.88u as=8.8p ps=40.88u w=20u l=1u
X739 a_33684_160275# a_33684_160275# VSS VSS nfet_06v0 ad=13p pd=50.52u as=13p ps=50.52u w=50u l=0.7u
X740 a_33684_160275# a_33684_148611# a_33684_148611# VSS nfet_06v0 ad=13p pd=50.52u as=13p ps=50.52u w=50u l=0.7u
X741 a_33684_148611# a_33684_148611# a_33684_160275# VSS nfet_06v0 ad=13p pd=50.52u as=13p ps=50.52u w=50u l=0.7u
X742 a_33684_160275# a_33684_148611# a_33684_148611# VSS nfet_06v0 ad=13p pd=50.52u as=13p ps=50.52u w=50u l=0.7u
X743 ESD_RAIL a_33005_131545# a_35813_117064# ESD_RAIL pfet_06v0 ad=1.3p pd=5.52u as=1.3p ps=5.52u w=5u l=0.7u
X744 a_33684_148611# a_33684_148611# a_33684_160275# VSS nfet_06v0 ad=13p pd=50.52u as=13p ps=50.52u w=50u l=0.7u
X745 a_33684_148611# a_33684_148611# a_33684_160275# VSS nfet_06v0 ad=13p pd=50.52u as=13p ps=50.52u w=50u l=0.7u
X746 a_33684_160275# a_33684_148611# a_33684_148611# VSS nfet_06v0 ad=13p pd=50.52u as=13p ps=50.52u w=50u l=0.7u
D16 VSS PAD_P diode_nd2ps_06v0 pj=51.8u area=22.5p
X747 PAD_N CASCODE SUM_N_D_1 VSS nfet_06v0 ad=7.04p pd=32.88u as=7.04p ps=32.88u w=16u l=0.7u
X748 TMDS_TAIL_3 TMDS_BIAS VSS VSS nfet_03v3 ad=8.8p pd=40.88u as=8.8p ps=40.88u w=20u l=1u
X749 DETECT_BLEED_3 DETECT_BLEED_4 VSS ppolyf_u_1k r_width=1u r_length=12.5u
X750 VSS a_33684_160275# a_33684_160275# VSS nfet_06v0 ad=13p pd=50.52u as=13p ps=50.52u w=50u l=0.7u
X751 a_33684_148611# a_33684_148611# a_33684_160275# VSS nfet_06v0 ad=13p pd=50.52u as=13p ps=50.52u w=50u l=0.7u
X752 a_33684_160275# a_33684_148611# a_33684_148611# VSS nfet_06v0 ad=13p pd=50.52u as=13p ps=50.52u w=50u l=0.7u
X753 TERM_P_R TERM_ENABLE_LOCAL TERM_VCM VSS nfet_03v3 ad=8.8p pd=40.88u as=8.8p ps=40.88u w=20u l=0.28u
X754 a_33684_160275# a_33684_160275# VSS VSS nfet_06v0 ad=13p pd=50.52u as=13p ps=50.52u w=50u l=0.7u
X755 PAD_N CASCODE SUM_N_D_3 VSS nfet_06v0 ad=7.04p pd=32.88u as=7.04p ps=32.88u w=16u l=0.7u
X756 ESD_RAIL ESD_RAIL a_33684_148611# VSS nfet_06v0 ad=13p pd=50.52u as=13p ps=50.52u w=50u l=0.7u
X757 SUM_P_D_3 TMDS_P TMDS_TAIL_3 VSS nfet_03v3 ad=8.8p pd=40.88u as=8.8p ps=40.88u w=20u l=0.28u
X758 VSS a_33684_160275# a_33684_160275# VSS nfet_06v0 ad=13p pd=50.52u as=13p ps=50.52u w=50u l=0.7u
X759 a_33684_148611# ESD_RAIL ESD_RAIL VSS nfet_06v0 ad=13p pd=50.52u as=13p ps=50.52u w=50u l=0.7u
X760 ESD_RAIL a_34245_90628# VSS VSS nfet_06v0 ad=13p pd=50.52u as=13p ps=50.52u w=50u l=0.7u
D17 VSS PAD_N diode_nd2ps_06v0 pj=51.8u area=22.5p
X761 POST_TAIL_1 POST_BIAS VSS VSS nfet_03v3 ad=8.8p pd=40.88u as=8.8p ps=40.88u w=20u l=1u
X762 a_33684_160275# a_33684_160275# VSS VSS nfet_06v0 ad=13p pd=50.52u as=13p ps=50.52u w=50u l=0.7u
X763 PAD_P CASCODE SUM_P_D_6 VSS nfet_06v0 ad=7.04p pd=32.88u as=7.04p ps=32.88u w=16u l=0.7u
X764 a_33684_160275# a_33684_148611# a_33684_148611# VSS nfet_06v0 ad=13p pd=50.52u as=13p ps=50.52u w=50u l=0.7u
X765 DETECT_N_I DETECT_ENABLE_LOCAL PAD_N VSS nfet_06v0 ad=1.76p pd=8.88u as=1.76p ps=8.88u w=4u l=0.7u
X766 a_33684_148611# a_33684_148611# a_33684_160275# VSS nfet_06v0 ad=13p pd=50.52u as=13p ps=50.52u w=50u l=0.7u
X767 a_34245_90628# a_36789_117064# ESD_RAIL ESD_RAIL pfet_06v0 ad=1.3p pd=5.52u as=1.3p ps=5.52u w=5u l=0.7u
X768 a_33684_160275# a_33684_160275# VSS VSS nfet_06v0 ad=13p pd=50.52u as=13p ps=50.52u w=50u l=0.7u
X769 VSS a_33684_160275# a_33684_160275# VSS nfet_06v0 ad=13p pd=50.52u as=13p ps=50.52u w=50u l=0.7u
X770 VSS a_34245_90628# ESD_RAIL VSS nfet_06v0 ad=13p pd=50.52u as=13p ps=50.52u w=50u l=0.7u
X771 a_33684_148611# ESD_RAIL ESD_RAIL VSS nfet_06v0 ad=13p pd=50.52u as=13p ps=50.52u w=50u l=0.7u
X772 ESD_RAIL ESD_RAIL a_33684_148611# VSS nfet_06v0 ad=13p pd=50.52u as=13p ps=50.52u w=50u l=0.7u
X773 SUM_P_D_2 POST_P POST_TAIL_2 VSS nfet_03v3 ad=8.8p pd=40.88u as=8.8p ps=40.88u w=20u l=0.28u
X774 VSS a_34245_90628# ESD_RAIL VSS nfet_06v0 ad=13p pd=50.52u as=13p ps=50.52u w=50u l=0.7u
X775 VSS a_33684_160275# a_33684_160275# VSS nfet_06v0 ad=13p pd=50.52u as=13p ps=50.52u w=50u l=0.7u
X776 a_33684_160275# a_33684_160275# VSS VSS nfet_06v0 ad=13p pd=50.52u as=13p ps=50.52u w=50u l=0.7u
X777 a_33684_160275# a_33684_160275# VSS VSS nfet_06v0 ad=13p pd=50.52u as=13p ps=50.52u w=50u l=0.7u
X778 DETECT_BLEED_1 DETECT_BLEED_2 VSS ppolyf_u_1k r_width=1u r_length=12.5u
X779 VSS a_33684_160275# a_33684_160275# VSS nfet_06v0 ad=13p pd=50.52u as=13p ps=50.52u w=50u l=0.7u
X780 ESD_RAIL a_34245_90628# VSS VSS nfet_06v0 ad=13p pd=50.52u as=13p ps=50.52u w=50u l=0.7u
X781 a_33684_148611# ESD_RAIL ESD_RAIL VSS nfet_06v0 ad=13p pd=50.52u as=13p ps=50.52u w=50u l=0.7u
X782 ESD_RAIL a_36789_117064# a_34245_90628# ESD_RAIL pfet_06v0 ad=1.3p pd=5.52u as=1.3p ps=5.52u w=5u l=0.7u
X783 VSS a_33684_160275# a_33684_160275# VSS nfet_06v0 ad=13p pd=50.52u as=13p ps=50.52u w=50u l=0.7u
X784 ESD_RAIL ESD_RAIL a_33684_148611# VSS nfet_06v0 ad=13p pd=50.52u as=13p ps=50.52u w=50u l=0.7u
X785 a_33684_148611# a_33684_148611# a_33684_160275# VSS nfet_06v0 ad=13p pd=50.52u as=13p ps=50.52u w=50u l=0.7u
X786 SUM_P_D_0 POST_P POST_TAIL_0 VSS nfet_03v3 ad=8.8p pd=40.88u as=8.8p ps=40.88u w=20u l=0.28u
X787 ESD_RAIL a_34245_90628# VSS VSS nfet_06v0 ad=13p pd=50.52u as=13p ps=50.52u w=50u l=0.7u
X788 ESD_RAIL a_34245_90628# VSS VSS nfet_06v0 ad=13p pd=50.52u as=13p ps=50.52u w=50u l=0.7u
X789 a_33684_148611# ESD_RAIL ESD_RAIL VSS nfet_06v0 ad=13p pd=50.52u as=13p ps=50.52u w=50u l=0.7u
X790 VSS a_33684_160275# a_33684_160275# VSS nfet_06v0 ad=13p pd=50.52u as=13p ps=50.52u w=50u l=0.7u
X791 a_33684_160275# a_33684_160275# VSS VSS nfet_06v0 ad=13p pd=50.52u as=13p ps=50.52u w=50u l=0.7u
X792 ESD_RAIL ESD_RAIL a_33684_148611# VSS nfet_06v0 ad=13p pd=50.52u as=13p ps=50.52u w=50u l=0.7u
X793 SUM_P_D_1 POST_P POST_TAIL_1 VSS nfet_03v3 ad=8.8p pd=40.88u as=8.8p ps=40.88u w=20u l=0.28u
X794 PAD_N CASCODE SUM_N_D_4 VSS nfet_06v0 ad=7.04p pd=32.88u as=7.04p ps=32.88u w=16u l=0.7u
X795 PAD_N TERM_N_R VSS ppolyf_s r_width=1u r_length=1.8u
X796 a_33684_160275# a_33684_148611# a_33684_148611# VSS nfet_06v0 ad=13p pd=50.52u as=13p ps=50.52u w=50u l=0.7u
X797 POST_TAIL_5 POST_BIAS VSS VSS nfet_03v3 ad=8.8p pd=40.88u as=8.8p ps=40.88u w=20u l=1u
X798 PAD_N CASCODE SUM_N_D_3 VSS nfet_06v0 ad=7.04p pd=32.88u as=7.04p ps=32.88u w=16u l=0.7u
X799 TMDS_TAIL_1 TMDS_BIAS VSS VSS nfet_03v3 ad=8.8p pd=40.88u as=8.8p ps=40.88u w=20u l=1u
X800 a_33684_160275# a_33684_160275# VSS VSS nfet_06v0 ad=13p pd=50.52u as=13p ps=50.52u w=50u l=0.7u
X801 a_33684_148611# ESD_RAIL ESD_RAIL VSS nfet_06v0 ad=13p pd=50.52u as=13p ps=50.52u w=50u l=0.7u
X802 ESD_RAIL ESD_RAIL a_33684_148611# VSS nfet_06v0 ad=13p pd=50.52u as=13p ps=50.52u w=50u l=0.7u
X803 SUM_N_D_7 TMDS_N TMDS_TAIL_7 VSS nfet_03v3 ad=8.8p pd=40.88u as=8.8p ps=40.88u w=20u l=0.28u
X804 a_33684_148611# ESD_RAIL ESD_RAIL VSS nfet_06v0 ad=13p pd=50.52u as=13p ps=50.52u w=50u l=0.7u
X805 ESD_RAIL a_34245_90628# VSS VSS nfet_06v0 ad=13p pd=50.52u as=13p ps=50.52u w=50u l=0.7u
X806 SUM_P_D_5 POST_P POST_TAIL_5 VSS nfet_03v3 ad=8.8p pd=40.88u as=8.8p ps=40.88u w=20u l=0.28u
X807 a_33684_160275# a_33684_160275# VSS VSS nfet_06v0 ad=13p pd=50.52u as=13p ps=50.52u w=50u l=0.7u
X808 ESD_RAIL ESD_RAIL a_33684_148611# VSS nfet_06v0 ad=13p pd=50.52u as=13p ps=50.52u w=50u l=0.7u
X809 ESD_RAIL ESD_RAIL a_33684_148611# VSS nfet_06v0 ad=13p pd=50.52u as=13p ps=50.52u w=50u l=0.7u
X810 ESD_RAIL a_36789_117064# a_34245_90628# ESD_RAIL pfet_06v0 ad=1.3p pd=5.52u as=1.3p ps=5.52u w=5u l=0.7u
X811 a_33684_148611# a_33684_148611# a_33684_160275# VSS nfet_06v0 ad=13p pd=50.52u as=13p ps=50.52u w=50u l=0.7u
X812 TERM_N_R TERM_ENABLE_LOCAL TERM_VCM VSS nfet_03v3 ad=8.8p pd=40.88u as=8.8p ps=40.88u w=20u l=0.28u
X813 a_33005_132385# a_45878_132105# ESD_RAIL ppolyf_u r_width=0.8u r_length=63.855u
X814 MAIN_TAIL_4 MAIN_BIAS VSS VSS nfet_03v3 ad=8.8p pd=40.88u as=8.8p ps=40.88u w=20u l=1u
X815 a_33684_160275# a_33684_160275# VSS VSS nfet_06v0 ad=13p pd=50.52u as=13p ps=50.52u w=50u l=0.7u
X816 VSS a_33684_160275# a_33684_160275# VSS nfet_06v0 ad=13p pd=50.52u as=13p ps=50.52u w=50u l=0.7u
X817 a_33684_148611# ESD_RAIL ESD_RAIL VSS nfet_06v0 ad=13p pd=50.52u as=13p ps=50.52u w=50u l=0.7u
X818 SUM_N_D_4 TMDS_N TMDS_TAIL_4 VSS nfet_03v3 ad=8.8p pd=40.88u as=8.8p ps=40.88u w=20u l=0.28u
X819 TERM_ENABLE_LOCAL TERM_ENABLE_B VDD VDD pfet_06v0 ad=1.76p pd=8.88u as=1.76p ps=8.88u w=4u l=0.55u
X820 TMDS_TAIL_7 TMDS_BIAS VSS VSS nfet_03v3 ad=8.8p pd=40.88u as=8.8p ps=40.88u w=20u l=1u
X821 VSS a_33684_160275# a_33684_160275# VSS nfet_06v0 ad=13p pd=50.52u as=13p ps=50.52u w=50u l=0.7u
X822 a_33684_148611# ESD_RAIL ESD_RAIL VSS nfet_06v0 ad=13p pd=50.52u as=13p ps=50.52u w=50u l=0.7u
X823 VSS a_34245_90628# ESD_RAIL VSS nfet_06v0 ad=13p pd=50.52u as=13p ps=50.52u w=50u l=0.7u
X824 POST_TAIL_7 POST_BIAS VSS VSS nfet_03v3 ad=8.8p pd=40.88u as=8.8p ps=40.88u w=20u l=1u
X825 ESD_RAIL a_34245_90628# VSS VSS nfet_06v0 ad=13p pd=50.52u as=13p ps=50.52u w=50u l=0.7u
X826 POST_TAIL_5 POST_BIAS VSS VSS nfet_03v3 ad=8.8p pd=40.88u as=8.8p ps=40.88u w=20u l=1u
X827 VSS a_33684_160275# a_33684_160275# VSS nfet_06v0 ad=13p pd=50.52u as=13p ps=50.52u w=50u l=0.7u
X828 a_33684_160275# a_33684_160275# VSS VSS nfet_06v0 ad=13p pd=50.52u as=13p ps=50.52u w=50u l=0.7u
X829 a_33684_148611# ESD_RAIL ESD_RAIL VSS nfet_06v0 ad=13p pd=50.52u as=13p ps=50.52u w=50u l=0.7u
X830 ESD_RAIL ESD_RAIL a_33684_148611# VSS nfet_06v0 ad=13p pd=50.52u as=13p ps=50.52u w=50u l=0.7u
X831 a_34245_90628# a_36789_117064# ESD_RAIL ESD_RAIL pfet_06v0 ad=1.3p pd=5.52u as=1.3p ps=5.52u w=5u l=0.7u
X832 a_33684_160275# a_33684_148611# a_33684_148611# VSS nfet_06v0 ad=13p pd=50.52u as=13p ps=50.52u w=50u l=0.7u
X833 ESD_RAIL a_33005_131545# a_35813_117064# ESD_RAIL pfet_06v0 ad=1.3p pd=5.52u as=1.3p ps=5.52u w=5u l=0.7u
X834 a_33684_160275# a_33684_160275# VSS VSS nfet_06v0 ad=13p pd=50.52u as=13p ps=50.52u w=50u l=0.7u
X835 ESD_RAIL ESD_RAIL a_33684_148611# VSS nfet_06v0 ad=13p pd=50.52u as=13p ps=50.52u w=50u l=0.7u
X836 a_33684_148611# a_33684_148611# a_33684_160275# VSS nfet_06v0 ad=13p pd=50.52u as=13p ps=50.52u w=50u l=0.7u
X837 a_33684_160275# a_33684_148611# a_33684_148611# VSS nfet_06v0 ad=13p pd=50.52u as=13p ps=50.52u w=50u l=0.7u
X838 a_33684_160275# a_33684_148611# a_33684_148611# VSS nfet_06v0 ad=13p pd=50.52u as=13p ps=50.52u w=50u l=0.7u
X839 TERM_P_R TERM_ENABLE_LOCAL TERM_VCM VSS nfet_03v3 ad=8.8p pd=40.88u as=8.8p ps=40.88u w=20u l=0.28u
X840 a_33684_160275# a_33684_160275# VSS VSS nfet_06v0 ad=13p pd=50.52u as=13p ps=50.52u w=50u l=0.7u
X841 ESD_RAIL ESD_RAIL a_33684_148611# VSS nfet_06v0 ad=13p pd=50.52u as=13p ps=50.52u w=50u l=0.7u
X842 a_33684_148611# a_33684_148611# a_33684_160275# VSS nfet_06v0 ad=13p pd=50.52u as=13p ps=50.52u w=50u l=0.7u
X843 PAD_N CASCODE SUM_N_D_1 VSS nfet_06v0 ad=7.04p pd=32.88u as=7.04p ps=32.88u w=16u l=0.7u
X844 MAIN_TAIL_1 MAIN_BIAS VSS VSS nfet_03v3 ad=8.8p pd=40.88u as=8.8p ps=40.88u w=20u l=1u
X845 a_33684_160275# a_33684_148611# a_33684_148611# VSS nfet_06v0 ad=13p pd=50.52u as=13p ps=50.52u w=50u l=0.7u
X846 TERM_ENABLE_B TERM_ENABLE VDD VDD pfet_06v0 ad=1.76p pd=8.88u as=1.76p ps=8.88u w=4u l=0.55u
X847 POST_TAIL_3 POST_BIAS VSS VSS nfet_03v3 ad=8.8p pd=40.88u as=8.8p ps=40.88u w=20u l=1u
X848 ESD_RAIL ESD_RAIL a_33684_148611# VSS nfet_06v0 ad=13p pd=50.52u as=13p ps=50.52u w=50u l=0.7u
X849 a_34245_90628# a_36789_117064# ESD_RAIL ESD_RAIL pfet_06v0 ad=1.3p pd=5.52u as=1.3p ps=5.52u w=5u l=0.7u
X850 PAD_N CASCODE SUM_N_D_0 VSS nfet_06v0 ad=7.04p pd=32.88u as=7.04p ps=32.88u w=16u l=0.7u
X851 POST_TAIL_6 POST_BIAS VSS VSS nfet_03v3 ad=8.8p pd=40.88u as=8.8p ps=40.88u w=20u l=1u
X852 a_33684_148611# ESD_RAIL ESD_RAIL VSS nfet_06v0 ad=13p pd=50.52u as=13p ps=50.52u w=50u l=0.7u
X853 TERM_N_R TERM_ENABLE_LOCAL TERM_VCM VSS nfet_03v3 ad=8.8p pd=40.88u as=8.8p ps=40.88u w=20u l=0.28u
X854 a_33684_148611# a_33684_148611# a_33684_160275# VSS nfet_06v0 ad=13p pd=50.52u as=13p ps=50.52u w=50u l=0.7u
X855 a_33684_148611# a_33684_148611# a_33684_160275# VSS nfet_06v0 ad=13p pd=50.52u as=13p ps=50.52u w=50u l=0.7u
X856 a_33684_160275# a_33684_148611# a_33684_148611# VSS nfet_06v0 ad=13p pd=50.52u as=13p ps=50.52u w=50u l=0.7u
X857 a_33684_160275# a_33684_148611# a_33684_148611# VSS nfet_06v0 ad=22p pd=0.10088m as=13p ps=50.52u w=50u l=0.7u
X858 PAD_N CASCODE SUM_N_D_7 VSS nfet_06v0 ad=7.04p pd=32.88u as=7.04p ps=32.88u w=16u l=0.7u
X859 POST_TAIL_4 POST_BIAS VSS VSS nfet_03v3 ad=8.8p pd=40.88u as=8.8p ps=40.88u w=20u l=1u
X860 a_33684_148611# a_33684_148611# a_33684_160275# VSS nfet_06v0 ad=13p pd=50.52u as=13p ps=50.52u w=50u l=0.7u
X861 a_33684_148611# ESD_RAIL ESD_RAIL VSS nfet_06v0 ad=13p pd=50.52u as=13p ps=50.52u w=50u l=0.7u
X862 a_33684_148611# a_33684_148611# a_33684_160275# VSS nfet_06v0 ad=13p pd=50.52u as=13p ps=50.52u w=50u l=0.7u
X863 a_33684_160275# a_33684_148611# a_33684_148611# VSS nfet_06v0 ad=13p pd=50.52u as=13p ps=50.52u w=50u l=0.7u
X864 ESD_RAIL a_34245_90628# VSS VSS nfet_06v0 ad=13p pd=50.52u as=13p ps=50.52u w=50u l=0.7u
X865 a_33684_160275# a_33684_148611# a_33684_148611# VSS nfet_06v0 ad=13p pd=50.52u as=13p ps=50.52u w=50u l=0.7u
X866 a_33684_148611# a_33684_148611# a_33684_160275# VSS nfet_06v0 ad=13p pd=50.52u as=13p ps=50.52u w=50u l=0.7u
X867 a_34245_90628# a_36789_117064# ESD_RAIL ESD_RAIL pfet_06v0 ad=1.3p pd=5.52u as=1.3p ps=5.52u w=5u l=0.7u
X868 MAIN_TAIL_2 MAIN_BIAS VSS VSS nfet_03v3 ad=8.8p pd=40.88u as=8.8p ps=40.88u w=20u l=1u
X869 a_33684_160275# a_33684_148611# a_33684_148611# VSS nfet_06v0 ad=13p pd=50.52u as=13p ps=50.52u w=50u l=0.7u
X870 a_33684_148611# a_33684_148611# a_33684_160275# VSS nfet_06v0 ad=13p pd=50.52u as=13p ps=50.52u w=50u l=0.7u
X871 a_33684_148611# ESD_RAIL ESD_RAIL VSS nfet_06v0 ad=13p pd=50.52u as=13p ps=50.52u w=50u l=0.7u
X872 ESD_RAIL ESD_RAIL a_33684_148611# VSS nfet_06v0 ad=13p pd=50.52u as=13p ps=50.52u w=50u l=0.7u
X873 a_33684_160275# a_33684_148611# a_33684_148611# VSS nfet_06v0 ad=13p pd=50.52u as=13p ps=50.52u w=50u l=0.7u
X874 ESD_RAIL a_34245_90628# VSS VSS nfet_06v0 ad=13p pd=50.52u as=13p ps=50.52u w=50u l=0.7u
X875 DETECT_BLEED_5 DETECT_BLEED_6 VSS ppolyf_u_1k r_width=1u r_length=12.5u
X876 a_33684_148611# a_33684_148611# a_33684_160275# VSS nfet_06v0 ad=13p pd=50.52u as=13p ps=50.52u w=50u l=0.7u
X877 a_33684_160275# a_33684_160275# VSS VSS nfet_06v0 ad=13p pd=50.52u as=13p ps=50.52u w=50u l=0.7u
X878 a_33684_160275# a_33684_160275# VSS VSS nfet_06v0 ad=13p pd=50.52u as=13p ps=50.52u w=50u l=0.7u
X879 ESD_RAIL ESD_RAIL a_33684_148611# VSS nfet_06v0 ad=13p pd=50.52u as=13p ps=50.52u w=50u l=0.7u
X880 a_33684_160275# a_33684_148611# a_33684_148611# VSS nfet_06v0 ad=13p pd=50.52u as=13p ps=50.52u w=50u l=0.7u
X881 a_33684_148611# a_33684_148611# a_33684_160275# VSS nfet_06v0 ad=13p pd=50.52u as=13p ps=50.52u w=50u l=0.7u
X882 a_33684_160275# a_33684_148611# a_33684_148611# VSS nfet_06v0 ad=13p pd=50.52u as=13p ps=50.52u w=50u l=0.7u
X883 SUM_P_D_3 MAIN_P MAIN_TAIL_3 VSS nfet_03v3 ad=8.8p pd=40.88u as=8.8p ps=40.88u w=20u l=0.28u
X884 ESD_RAIL a_34245_90628# VSS VSS nfet_06v0 ad=13p pd=50.52u as=13p ps=50.52u w=50u l=0.7u
X885 a_33005_131825# a_45878_132105# ESD_RAIL ppolyf_u r_width=0.8u r_length=63.855u
X886 TERM_ENABLE_B TERM_ENABLE VSS VSS nfet_06v0 ad=0.88p pd=4.88u as=0.88p ps=4.88u w=2u l=0.7u
X887 a_33684_160275# a_33684_148611# a_33684_148611# VSS nfet_06v0 ad=13p pd=50.52u as=13p ps=50.52u w=50u l=0.7u
X888 ESD_RAIL ESD_RAIL a_33684_148611# VSS nfet_06v0 ad=13p pd=50.52u as=13p ps=50.52u w=50u l=0.7u
X889 a_33684_148611# a_33684_148611# a_33684_160275# VSS nfet_06v0 ad=13p pd=50.52u as=13p ps=50.52u w=50u l=0.7u
X890 a_33684_160275# a_33684_160275# VSS VSS nfet_06v0 ad=13p pd=50.52u as=13p ps=50.52u w=50u l=0.7u
X891 a_33684_148611# a_33684_148611# a_33684_160275# VSS nfet_06v0 ad=13p pd=50.52u as=13p ps=50.52u w=50u l=0.7u
X892 a_33684_160275# a_33684_148611# a_33684_148611# VSS nfet_06v0 ad=13p pd=50.52u as=13p ps=50.52u w=50u l=0.7u
X893 ESD_RAIL a_34245_90628# VSS VSS nfet_06v0 ad=13p pd=50.52u as=13p ps=50.52u w=50u l=0.7u
X894 ESD_RAIL a_36789_117064# a_34245_90628# ESD_RAIL pfet_06v0 ad=1.3p pd=5.52u as=1.3p ps=5.52u w=5u l=0.7u
X895 VSS a_33684_160275# a_33684_160275# VSS nfet_06v0 ad=13p pd=50.52u as=13p ps=50.52u w=50u l=0.7u
X896 ESD_RAIL a_34245_90628# VSS VSS nfet_06v0 ad=13p pd=50.52u as=13p ps=50.52u w=50u l=0.7u
X897 a_33684_148611# a_33684_148611# a_33684_160275# VSS nfet_06v0 ad=13p pd=50.52u as=13p ps=50.52u w=50u l=0.7u
X898 a_34245_90628# a_36789_117064# ESD_RAIL ESD_RAIL pfet_06v0 ad=1.3p pd=5.52u as=1.3p ps=5.52u w=5u l=0.7u
X899 a_33684_160275# a_33684_160275# VSS VSS nfet_06v0 ad=13p pd=50.52u as=13p ps=50.52u w=50u l=0.7u
X900 a_33684_148611# a_33684_148611# a_33684_160275# VSS nfet_06v0 ad=13p pd=50.52u as=13p ps=50.52u w=50u l=0.7u
X901 VSS a_34245_90628# ESD_RAIL VSS nfet_06v0 ad=13p pd=50.52u as=13p ps=50.52u w=50u l=0.7u
X902 a_33684_160275# a_33684_160275# VSS VSS nfet_06v0 ad=13p pd=50.52u as=13p ps=50.52u w=50u l=0.7u
X903 a_33684_160275# a_33684_148611# a_33684_148611# VSS nfet_06v0 ad=13p pd=50.52u as=13p ps=50.52u w=50u l=0.7u
X904 VSS a_33684_160275# a_33684_160275# VSS nfet_06v0 ad=13p pd=50.52u as=13p ps=50.52u w=50u l=0.7u
X905 VSS a_33684_160275# a_33684_160275# VSS nfet_06v0 ad=13p pd=50.52u as=13p ps=50.52u w=50u l=0.7u
X906 DETECT_ENABLE_LOCAL DETECT_ENABLE_B VSS VSS nfet_06v0 ad=0.88p pd=4.88u as=0.88p ps=4.88u w=2u l=0.7u
X907 a_33684_148611# a_33684_148611# a_33684_160275# VSS nfet_06v0 ad=13p pd=50.52u as=13p ps=50.52u w=50u l=0.7u
X908 a_33684_160275# a_33684_160275# VSS VSS nfet_06v0 ad=13p pd=50.52u as=13p ps=50.52u w=50u l=0.7u
X909 VSS a_33684_160275# a_33684_160275# VSS nfet_06v0 ad=13p pd=50.52u as=13p ps=50.52u w=50u l=0.7u
X910 a_33684_160275# a_33684_148611# a_33684_148611# VSS nfet_06v0 ad=13p pd=50.52u as=13p ps=50.52u w=50u l=0.7u
X911 a_33684_148611# a_33684_148611# a_33684_160275# VSS nfet_06v0 ad=13p pd=50.52u as=13p ps=50.52u w=50u l=0.7u
X912 SUM_N_D_0 TMDS_N TMDS_TAIL_0 VSS nfet_03v3 ad=8.8p pd=40.88u as=8.8p ps=40.88u w=20u l=0.28u
X913 a_33684_160275# a_33684_160275# VSS VSS nfet_06v0 ad=13p pd=50.52u as=13p ps=50.52u w=50u l=0.7u
X914 a_33684_160275# a_33684_148611# a_33684_148611# VSS nfet_06v0 ad=13p pd=50.52u as=13p ps=50.52u w=50u l=0.7u
X915 VSS a_34245_90628# ESD_RAIL VSS nfet_06v0 ad=13p pd=50.52u as=13p ps=50.52u w=50u l=0.7u
X916 a_33684_160275# a_33684_148611# a_33684_148611# VSS nfet_06v0 ad=13p pd=50.52u as=13p ps=50.52u w=50u l=0.7u
X917 SUM_P_D_2 MAIN_P MAIN_TAIL_2 VSS nfet_03v3 ad=8.8p pd=40.88u as=8.8p ps=40.88u w=20u l=0.28u
X918 VSS a_33684_160275# a_33684_160275# VSS nfet_06v0 ad=13p pd=50.52u as=13p ps=50.52u w=50u l=0.7u
X919 a_33684_148611# a_33684_148611# a_33684_160275# VSS nfet_06v0 ad=13p pd=50.52u as=13p ps=50.52u w=50u l=0.7u
X920 a_33684_148611# a_33684_148611# a_33684_160275# VSS nfet_06v0 ad=13p pd=50.52u as=13p ps=50.52u w=50u l=0.7u
X921 ESD_RAIL a_36789_117064# a_34245_90628# ESD_RAIL pfet_06v0 ad=1.3p pd=5.52u as=1.3p ps=5.52u w=5u l=0.7u
X922 a_33684_160275# a_33684_160275# VSS VSS nfet_06v0 ad=13p pd=50.52u as=13p ps=50.52u w=50u l=0.7u
X923 a_33684_160275# a_33684_160275# VSS VSS nfet_06v0 ad=13p pd=50.52u as=13p ps=50.52u w=50u l=0.7u
X924 ESD_RAIL ESD_RAIL a_33684_148611# VSS nfet_06v0 ad=13p pd=50.52u as=13p ps=50.52u w=50u l=0.7u
X925 MAIN_TAIL_6 MAIN_BIAS VSS VSS nfet_03v3 ad=8.8p pd=40.88u as=8.8p ps=40.88u w=20u l=1u
X926 ESD_RAIL ESD_RAIL a_33684_148611# VSS nfet_06v0 ad=13p pd=50.52u as=13p ps=50.52u w=50u l=0.7u
X927 a_33684_160275# a_33684_148611# a_33684_148611# VSS nfet_06v0 ad=13p pd=50.52u as=13p ps=50.52u w=50u l=0.7u
X928 ESD_RAIL a_36789_117064# a_34245_90628# ESD_RAIL pfet_06v0 ad=1.3p pd=5.52u as=1.3p ps=5.52u w=5u l=0.7u
X929 VSS a_33684_160275# a_33684_160275# VSS nfet_06v0 ad=13p pd=50.52u as=13p ps=50.52u w=50u l=0.7u
X930 a_33684_160275# a_33684_148611# a_33684_148611# VSS nfet_06v0 ad=13p pd=50.52u as=13p ps=50.52u w=50u l=0.7u
X931 a_33684_160275# a_33684_160275# VSS VSS nfet_06v0 ad=13p pd=50.52u as=13p ps=50.52u w=50u l=0.7u
X932 a_33684_148611# a_33684_148611# a_33684_160275# VSS nfet_06v0 ad=13p pd=50.52u as=13p ps=50.52u w=50u l=0.7u
X933 ESD_RAIL a_34245_90628# VSS VSS nfet_06v0 ad=22p pd=0.10088m as=13p ps=50.52u w=50u l=0.7u
X934 a_33684_160275# a_33684_160275# VSS VSS nfet_06v0 ad=13p pd=50.52u as=13p ps=50.52u w=50u l=0.7u
X935 VSS a_33684_160275# a_33684_160275# VSS nfet_06v0 ad=13p pd=50.52u as=13p ps=50.52u w=50u l=0.7u
X936 MAIN_TAIL_7 MAIN_BIAS VSS VSS nfet_03v3 ad=8.8p pd=40.88u as=8.8p ps=40.88u w=20u l=1u
X937 TMDS_TAIL_0 TMDS_BIAS VSS VSS nfet_03v3 ad=8.8p pd=40.88u as=8.8p ps=40.88u w=20u l=1u
X938 SUM_P_D_6 MAIN_P MAIN_TAIL_6 VSS nfet_03v3 ad=8.8p pd=40.88u as=8.8p ps=40.88u w=20u l=0.28u
X939 VSS a_33684_160275# a_33684_160275# VSS nfet_06v0 ad=13p pd=50.52u as=13p ps=50.52u w=50u l=0.7u
X940 a_33005_132945# a_45878_133225# ESD_RAIL ppolyf_u r_width=0.8u r_length=63.855u
X941 ESD_RAIL ESD_RAIL a_33684_148611# VSS nfet_06v0 ad=13p pd=50.52u as=13p ps=50.52u w=50u l=0.7u
X942 a_33684_160275# a_33684_160275# VSS VSS nfet_06v0 ad=13p pd=50.52u as=13p ps=50.52u w=50u l=0.7u
X943 a_33684_160275# a_33684_148611# a_33684_148611# VSS nfet_06v0 ad=13p pd=50.52u as=13p ps=50.52u w=50u l=0.7u
X944 DETECT_P_I DETECT_PBIAS VDD VDD pfet_03v3 ad=1.76p pd=8.88u as=1.76p ps=8.88u w=4u l=2u
X945 VSS a_33684_160275# a_33684_160275# VSS nfet_06v0 ad=13p pd=50.52u as=13p ps=50.52u w=50u l=0.7u
X946 a_33684_148611# ESD_RAIL ESD_RAIL VSS nfet_06v0 ad=13p pd=50.52u as=13p ps=50.52u w=50u l=0.7u
X947 VSS a_34245_90628# ESD_RAIL VSS nfet_06v0 ad=13p pd=50.52u as=22p ps=0.10088m w=50u l=0.7u
X948 SUM_N_D_6 TMDS_N TMDS_TAIL_6 VSS nfet_03v3 ad=8.8p pd=40.88u as=8.8p ps=40.88u w=20u l=0.28u
X949 a_33684_148611# a_33684_148611# a_33684_160275# VSS nfet_06v0 ad=13p pd=50.52u as=13p ps=50.52u w=50u l=0.7u
X950 a_33684_160275# a_33684_160275# VSS VSS nfet_06v0 ad=13p pd=50.52u as=13p ps=50.52u w=50u l=0.7u
X951 a_33684_160275# a_33684_148611# a_33684_148611# VSS nfet_06v0 ad=13p pd=50.52u as=13p ps=50.52u w=50u l=0.7u
X952 a_33684_148611# a_33684_148611# a_33684_160275# VSS nfet_06v0 ad=13p pd=50.52u as=13p ps=50.52u w=50u l=0.7u
X953 ESD_RAIL ESD_RAIL a_33684_148611# VSS nfet_06v0 ad=13p pd=50.52u as=13p ps=50.52u w=50u l=0.7u
X954 a_33684_160275# a_33684_148611# a_33684_148611# VSS nfet_06v0 ad=13p pd=50.52u as=13p ps=50.52u w=50u l=0.7u
X955 a_34245_90628# a_36789_117064# VSS VSS nfet_06v0 ad=1.3p pd=5.52u as=1.3p ps=5.52u w=5u l=0.7u
X956 ESD_RAIL a_36789_117064# a_34245_90628# ESD_RAIL pfet_06v0 ad=1.3p pd=5.52u as=1.3p ps=5.52u w=5u l=0.7u
X957 ESD_RAIL ESD_RAIL a_33684_148611# VSS nfet_06v0 ad=13p pd=50.52u as=13p ps=50.52u w=50u l=0.7u
X958 VSS a_33684_160275# a_33684_160275# VSS nfet_06v0 ad=13p pd=50.52u as=13p ps=50.52u w=50u l=0.7u
X959 a_33684_160275# a_33684_160275# VSS VSS nfet_06v0 ad=13p pd=50.52u as=13p ps=50.52u w=50u l=0.7u
X960 VSS a_33684_160275# a_33684_160275# VSS nfet_06v0 ad=13p pd=50.52u as=13p ps=50.52u w=50u l=0.7u
X961 a_33684_148611# ESD_RAIL ESD_RAIL VSS nfet_06v0 ad=13p pd=50.52u as=13p ps=50.52u w=50u l=0.7u
X962 VSS a_34245_90628# ESD_RAIL VSS nfet_06v0 ad=13p pd=50.52u as=22p ps=0.10088m w=50u l=0.7u
X963 a_33684_148611# ESD_RAIL ESD_RAIL VSS nfet_06v0 ad=13p pd=50.52u as=13p ps=50.52u w=50u l=0.7u
X964 a_33684_148611# a_33684_148611# a_33684_160275# VSS nfet_06v0 ad=13p pd=50.52u as=13p ps=50.52u w=50u l=0.7u
X965 a_34245_90628# a_36789_117064# ESD_RAIL ESD_RAIL pfet_06v0 ad=1.3p pd=5.52u as=2.2p ps=10.88u w=5u l=0.7u
X966 a_33684_160275# a_33684_160275# VSS VSS nfet_06v0 ad=13p pd=50.52u as=13p ps=50.52u w=50u l=0.7u
X967 POST_TAIL_0 POST_BIAS VSS VSS nfet_03v3 ad=8.8p pd=40.88u as=8.8p ps=40.88u w=20u l=1u
X968 ESD_RAIL ESD_RAIL a_33684_148611# VSS nfet_06v0 ad=13p pd=50.52u as=13p ps=50.52u w=50u l=0.7u
X969 a_35813_117064# a_33005_131545# VSS VSS nfet_06v0 ad=2.2p pd=10.88u as=2.2p ps=10.88u w=5u l=0.7u
X970 VSS a_33684_160275# a_33684_160275# VSS nfet_06v0 ad=13p pd=50.52u as=13p ps=50.52u w=50u l=0.7u
X971 a_33684_148611# ESD_RAIL ESD_RAIL VSS nfet_06v0 ad=13p pd=50.52u as=13p ps=50.52u w=50u l=0.7u
X972 VSS a_33684_160275# a_33684_160275# VSS nfet_06v0 ad=13p pd=50.52u as=13p ps=50.52u w=50u l=0.7u
X973 a_33684_160275# a_33684_160275# VSS VSS nfet_06v0 ad=13p pd=50.52u as=13p ps=50.52u w=50u l=0.7u
X974 ESD_RAIL ESD_RAIL a_33684_148611# VSS nfet_06v0 ad=13p pd=50.52u as=13p ps=50.52u w=50u l=0.7u
X975 MAIN_TAIL_6 MAIN_BIAS VSS VSS nfet_03v3 ad=8.8p pd=40.88u as=8.8p ps=40.88u w=20u l=1u
X976 VSS a_33684_160275# a_33684_160275# VSS nfet_06v0 ad=13p pd=50.52u as=13p ps=50.52u w=50u l=0.7u
X977 PAD_P CASCODE SUM_P_D_4 VSS nfet_06v0 ad=7.04p pd=32.88u as=7.04p ps=32.88u w=16u l=0.7u
X978 a_33684_148611# ESD_RAIL ESD_RAIL VSS nfet_06v0 ad=13p pd=50.52u as=13p ps=50.52u w=50u l=0.7u
X979 VSS a_33684_160275# a_33684_160275# VSS nfet_06v0 ad=13p pd=50.52u as=13p ps=50.52u w=50u l=0.7u
X980 a_33684_160275# a_33684_160275# VSS VSS nfet_06v0 ad=13p pd=50.52u as=13p ps=50.52u w=50u l=0.7u
X981 ESD_RAIL ESD_RAIL a_33684_148611# VSS nfet_06v0 ad=13p pd=50.52u as=13p ps=50.52u w=50u l=0.7u
X982 ESD_RAIL ESD_RAIL a_33684_148611# VSS nfet_06v0 ad=13p pd=50.52u as=13p ps=50.52u w=50u l=0.7u
X983 ESD_RAIL a_34245_90628# VSS VSS nfet_06v0 ad=13p pd=50.52u as=13p ps=50.52u w=50u l=0.7u
D18 PAD_P ESD_RAIL diode_pd2nw_06v0 pj=51.8u area=22.5p
X984 VSS a_33684_160275# a_33684_160275# VSS nfet_06v0 ad=13p pd=50.52u as=13p ps=50.52u w=50u l=0.7u
X985 a_33684_148611# ESD_RAIL ESD_RAIL VSS nfet_06v0 ad=13p pd=50.52u as=13p ps=50.52u w=50u l=0.7u
X986 VSS a_34245_90628# ESD_RAIL VSS nfet_06v0 ad=13p pd=50.52u as=13p ps=50.52u w=50u l=0.7u
X987 ESD_RAIL ESD_RAIL a_33684_148611# VSS nfet_06v0 ad=13p pd=50.52u as=13p ps=50.52u w=50u l=0.7u
X988 VSS a_35813_117064# a_36789_117064# VSS nfet_06v0 ad=1.3p pd=5.52u as=1.3p ps=5.52u w=5u l=0.7u
X989 a_34245_90628# a_36789_117064# ESD_RAIL ESD_RAIL pfet_06v0 ad=1.3p pd=5.52u as=1.3p ps=5.52u w=5u l=0.7u
X990 ESD_RAIL ESD_RAIL a_33684_148611# VSS nfet_06v0 ad=13p pd=50.52u as=13p ps=50.52u w=50u l=0.7u
X991 a_33684_160275# a_33684_160275# VSS VSS nfet_06v0 ad=13p pd=50.52u as=13p ps=50.52u w=50u l=0.7u
X992 ESD_RAIL a_34245_90628# VSS VSS nfet_06v0 ad=13p pd=50.52u as=13p ps=50.52u w=50u l=0.7u
X993 a_33684_148611# ESD_RAIL ESD_RAIL VSS nfet_06v0 ad=13p pd=50.52u as=13p ps=50.52u w=50u l=0.7u
X994 a_33684_160275# a_33684_160275# VSS VSS nfet_06v0 ad=13p pd=50.52u as=13p ps=50.52u w=50u l=0.7u
X995 VSS a_33684_160275# a_33684_160275# VSS nfet_06v0 ad=13p pd=50.52u as=13p ps=50.52u w=50u l=0.7u
X996 a_33684_148611# ESD_RAIL ESD_RAIL VSS nfet_06v0 ad=13p pd=50.52u as=13p ps=50.52u w=50u l=0.7u
X997 a_33684_160275# a_33684_160275# VSS VSS nfet_06v0 ad=13p pd=50.52u as=13p ps=50.52u w=50u l=0.7u
X998 a_33684_160275# a_33684_160275# VSS VSS nfet_06v0 ad=13p pd=50.52u as=13p ps=50.52u w=50u l=0.7u
X999 VSS a_33684_160275# a_33684_160275# VSS nfet_06v0 ad=13p pd=50.52u as=13p ps=50.52u w=50u l=0.7u
X1000 a_33005_134065# a_45878_134345# ESD_RAIL ppolyf_u r_width=0.8u r_length=63.855u
X1001 ESD_RAIL ESD_RAIL a_33684_148611# VSS nfet_06v0 ad=13p pd=50.52u as=13p ps=50.52u w=50u l=0.7u
X1002 SUM_N_D_3 POST_N POST_TAIL_3 VSS nfet_03v3 ad=8.8p pd=40.88u as=8.8p ps=40.88u w=20u l=0.28u
X1003 MAIN_TAIL_4 MAIN_BIAS VSS VSS nfet_03v3 ad=8.8p pd=40.88u as=8.8p ps=40.88u w=20u l=1u
X1004 a_33684_148611# ESD_RAIL ESD_RAIL VSS nfet_06v0 ad=13p pd=50.52u as=13p ps=50.52u w=50u l=0.7u
D19 PAD_N ESD_RAIL diode_pd2nw_06v0 pj=51.8u area=22.5p
X1005 SUM_N_D_5 TMDS_N TMDS_TAIL_5 VSS nfet_03v3 ad=8.8p pd=40.88u as=8.8p ps=40.88u w=20u l=0.28u
X1006 TMDS_TAIL_4 TMDS_BIAS VSS VSS nfet_03v3 ad=8.8p pd=40.88u as=8.8p ps=40.88u w=20u l=1u
X1007 a_33684_160275# a_33684_160275# VSS VSS nfet_06v0 ad=13p pd=50.52u as=13p ps=50.52u w=50u l=0.7u
X1008 VSS a_33684_160275# a_33684_160275# VSS nfet_06v0 ad=13p pd=50.52u as=13p ps=50.52u w=50u l=0.7u
X1009 PAD_N CASCODE SUM_N_D_2 VSS nfet_06v0 ad=7.04p pd=32.88u as=7.04p ps=32.88u w=16u l=0.7u
X1010 ESD_RAIL ESD_RAIL a_33684_148611# VSS nfet_06v0 ad=13p pd=50.52u as=13p ps=50.52u w=50u l=0.7u
X1011 a_33684_160275# a_33684_160275# VSS VSS nfet_06v0 ad=13p pd=50.52u as=13p ps=50.52u w=50u l=0.7u
X1012 ESD_RAIL a_34245_90628# VSS VSS nfet_06v0 ad=13p pd=50.52u as=13p ps=50.52u w=50u l=0.7u
X1013 a_33684_148611# ESD_RAIL ESD_RAIL VSS nfet_06v0 ad=13p pd=50.52u as=13p ps=50.52u w=50u l=0.7u
X1014 VSS a_35813_117064# a_36789_117064# VSS nfet_06v0 ad=1.3p pd=5.52u as=1.3p ps=5.52u w=5u l=0.7u
X1015 a_33684_148611# ESD_RAIL ESD_RAIL VSS nfet_06v0 ad=13p pd=50.52u as=13p ps=50.52u w=50u l=0.7u
X1016 ESD_RAIL ESD_RAIL a_33684_148611# VSS nfet_06v0 ad=13p pd=50.52u as=13p ps=50.52u w=50u l=0.7u
X1017 a_33684_160275# a_33684_148611# a_33684_148611# VSS nfet_06v0 ad=13p pd=50.52u as=13p ps=50.52u w=50u l=0.7u
X1018 MAIN_TAIL_5 MAIN_BIAS VSS VSS nfet_03v3 ad=8.8p pd=40.88u as=8.8p ps=40.88u w=20u l=1u
X1019 a_33684_160275# a_33684_160275# VSS VSS nfet_06v0 ad=13p pd=50.52u as=13p ps=50.52u w=50u l=0.7u
X1020 ESD_RAIL ESD_RAIL a_33684_148611# VSS nfet_06v0 ad=13p pd=50.52u as=13p ps=50.52u w=50u l=0.7u
X1021 a_33684_148611# ESD_RAIL ESD_RAIL VSS nfet_06v0 ad=13p pd=50.52u as=13p ps=50.52u w=50u l=0.7u
X1022 PAD_N CASCODE SUM_N_D_6 VSS nfet_06v0 ad=7.04p pd=32.88u as=7.04p ps=32.88u w=16u l=0.7u
X1023 a_33684_148611# ESD_RAIL ESD_RAIL VSS nfet_06v0 ad=13p pd=50.52u as=13p ps=50.52u w=50u l=0.7u
X1024 ESD_RAIL ESD_RAIL a_33684_148611# VSS nfet_06v0 ad=13p pd=50.52u as=13p ps=50.52u w=50u l=0.7u
X1025 POST_TAIL_3 POST_BIAS VSS VSS nfet_03v3 ad=8.8p pd=40.88u as=8.8p ps=40.88u w=20u l=1u
X1026 a_33684_160275# a_33684_148611# a_33684_148611# VSS nfet_06v0 ad=13p pd=50.52u as=13p ps=50.52u w=50u l=0.7u
X1027 a_33684_148611# ESD_RAIL ESD_RAIL VSS nfet_06v0 ad=13p pd=50.52u as=13p ps=50.52u w=50u l=0.7u
X1028 a_33684_148611# ESD_RAIL ESD_RAIL VSS nfet_06v0 ad=13p pd=50.52u as=13p ps=50.52u w=50u l=0.7u
X1029 SUM_N_D_1 POST_N POST_TAIL_1 VSS nfet_03v3 ad=8.8p pd=40.88u as=8.8p ps=40.88u w=20u l=0.28u
X1030 a_33684_160275# a_33684_148611# a_33684_148611# VSS nfet_06v0 ad=13p pd=50.52u as=13p ps=50.52u w=50u l=0.7u
X1031 ESD_RAIL ESD_RAIL a_33684_148611# VSS nfet_06v0 ad=13p pd=50.52u as=13p ps=50.52u w=50u l=0.7u
X1032 a_33684_148611# a_33684_148611# a_33684_160275# VSS nfet_06v0 ad=13p pd=50.52u as=13p ps=50.52u w=50u l=0.7u
X1033 TMDS_TAIL_1 TMDS_BIAS VSS VSS nfet_03v3 ad=8.8p pd=40.88u as=8.8p ps=40.88u w=20u l=1u
X1034 a_33684_160275# a_33684_160275# VSS VSS nfet_06v0 ad=13p pd=50.52u as=13p ps=50.52u w=50u l=0.7u
X1035 a_33684_148611# ESD_RAIL ESD_RAIL VSS nfet_06v0 ad=13p pd=50.52u as=13p ps=50.52u w=50u l=0.7u
X1036 ESD_RAIL ESD_RAIL a_33684_148611# VSS nfet_06v0 ad=13p pd=50.52u as=13p ps=50.52u w=50u l=0.7u
X1037 ESD_RAIL a_34245_90628# VSS VSS nfet_06v0 ad=13p pd=50.52u as=13p ps=50.52u w=50u l=0.7u
X1038 a_33684_148611# a_33684_148611# a_33684_160275# VSS nfet_06v0 ad=13p pd=50.52u as=13p ps=50.52u w=50u l=0.7u
X1039 ESD_RAIL ESD_RAIL a_33684_148611# VSS nfet_06v0 ad=13p pd=50.52u as=13p ps=50.52u w=50u l=0.7u
X1040 a_33684_148611# ESD_RAIL ESD_RAIL VSS nfet_06v0 ad=13p pd=50.52u as=13p ps=50.52u w=50u l=0.7u
X1041 PAD_P CASCODE SUM_P_D_1 VSS nfet_06v0 ad=7.04p pd=32.88u as=7.04p ps=32.88u w=16u l=0.7u
X1042 SUM_N_D_1 TMDS_N TMDS_TAIL_1 VSS nfet_03v3 ad=8.8p pd=40.88u as=8.8p ps=40.88u w=20u l=0.28u
X1043 ESD_RAIL ESD_RAIL a_33684_148611# VSS nfet_06v0 ad=13p pd=50.52u as=13p ps=50.52u w=50u l=0.7u
X1044 a_33684_148611# ESD_RAIL ESD_RAIL VSS nfet_06v0 ad=13p pd=50.52u as=13p ps=50.52u w=50u l=0.7u
X1045 ESD_RAIL ESD_RAIL a_33684_148611# VSS nfet_06v0 ad=13p pd=50.52u as=13p ps=50.52u w=50u l=0.7u
X1046 a_33684_148611# a_33684_148611# a_33684_160275# VSS nfet_06v0 ad=13p pd=50.52u as=13p ps=50.52u w=50u l=0.7u
X1047 VSS a_33684_160275# a_33684_160275# VSS nfet_06v0 ad=13p pd=50.52u as=13p ps=50.52u w=50u l=0.7u
X1048 ESD_RAIL ESD_RAIL a_33684_148611# VSS nfet_06v0 ad=13p pd=50.52u as=13p ps=50.52u w=50u l=0.7u
X1049 a_33684_148611# ESD_RAIL ESD_RAIL VSS nfet_06v0 ad=13p pd=50.52u as=13p ps=50.52u w=50u l=0.7u
X1050 ESD_RAIL ESD_RAIL a_33684_148611# VSS nfet_06v0 ad=13p pd=50.52u as=13p ps=50.52u w=50u l=0.7u
X1051 a_33684_148611# a_33684_148611# a_33684_160275# VSS nfet_06v0 ad=13p pd=50.52u as=13p ps=50.52u w=50u l=0.7u
X1052 a_33684_160275# a_33684_148611# a_33684_148611# VSS nfet_06v0 ad=13p pd=50.52u as=13p ps=50.52u w=50u l=0.7u
X1053 ESD_RAIL ESD_RAIL a_33684_148611# VSS nfet_06v0 ad=13p pd=50.52u as=13p ps=50.52u w=50u l=0.7u
X1054 a_33684_160275# a_33684_160275# VSS VSS nfet_06v0 ad=13p pd=50.52u as=13p ps=50.52u w=50u l=0.7u
X1055 a_33684_160275# a_33684_148611# a_33684_148611# VSS nfet_06v0 ad=13p pd=50.52u as=13p ps=50.52u w=50u l=0.7u
X1056 a_33684_160275# a_33684_148611# a_33684_148611# VSS nfet_06v0 ad=13p pd=50.52u as=13p ps=50.52u w=50u l=0.7u
X1057 ESD_RAIL a_34245_90628# VSS VSS nfet_06v0 ad=13p pd=50.52u as=13p ps=50.52u w=50u l=0.7u
X1058 PAD_N CASCODE SUM_N_D_5 VSS nfet_06v0 ad=7.04p pd=32.88u as=7.04p ps=32.88u w=16u l=0.7u
X1059 a_33684_160275# a_33684_148611# a_33684_148611# VSS nfet_06v0 ad=13p pd=50.52u as=13p ps=50.52u w=50u l=0.7u
X1060 SUM_N_D_7 POST_N POST_TAIL_7 VSS nfet_03v3 ad=8.8p pd=40.88u as=8.8p ps=40.88u w=20u l=0.28u
X1061 ESD_RAIL ESD_RAIL a_33684_148611# VSS nfet_06v0 ad=13p pd=50.52u as=13p ps=50.52u w=50u l=0.7u
X1062 a_33684_148611# a_33684_148611# a_33684_160275# VSS nfet_06v0 ad=13p pd=50.52u as=13p ps=50.52u w=50u l=0.7u
X1063 MAIN_TAIL_0 MAIN_BIAS VSS VSS nfet_03v3 ad=8.8p pd=40.88u as=8.8p ps=40.88u w=20u l=1u
X1064 a_33684_148611# a_33684_148611# a_33684_160275# VSS nfet_06v0 ad=13p pd=50.52u as=13p ps=50.52u w=50u l=0.7u
X1065 POST_TAIL_1 POST_BIAS VSS VSS nfet_03v3 ad=8.8p pd=40.88u as=8.8p ps=40.88u w=20u l=1u
X1066 VSS a_34245_90628# ESD_RAIL VSS nfet_06v0 ad=13p pd=50.52u as=13p ps=50.52u w=50u l=0.7u
X1067 VSS a_36789_117064# a_34245_90628# VSS nfet_06v0 ad=1.3p pd=5.52u as=1.3p ps=5.52u w=5u l=0.7u
C0 TMDS_TAIL_1 TMDS_TAIL_2 0.02585f
C1 TMDS_BIAS DETECT_BLEED_6 0.0479f
C2 DETECT_P_I DETECT_BLEED_0 0.03621f
C3 MAIN_P MAIN_TAIL_1 7.55933f
C4 SUM_N_D_4 SUM_P_D_5 0.16393f
C5 MAIN_N MAIN_TAIL_6 0.83648f
C6 CASCODE DETECT_ENABLE_LOCAL 0.07776f
C7 PAD_N TERM_N_R 4.26227f
C8 SUM_P_D_6 POST_TAIL_6 1.88107f
C9 TERM_BLEED_4 TERM_BLEED_3 2.0077f
C10 TMDS_BIAS MAIN_N 0.07262f
C11 POST_N TERM_BLEED_4 0
C12 POST_TAIL_6 SUM_N_D_2 0.12382f
C13 SUM_P_D_7 POST_TAIL_3 0.13042f
C14 TERM_BLEED_4 TERM_P_R 0.00257f
C15 CASCODE DETECT_BLEED_6 0.13962f
C16 SUM_N_D_3 POST_TAIL_3 1.86911f
C17 SUM_N_D_4 SUM_N_D_5 0.10013p
C18 MAIN_BIAS DETECT_BLEED_3 0.06178f
C19 TMDS_TAIL_2 SUM_P_D_5 0.0858f
C20 TMDS_BIAS DETECT_ENABLE_B 0.19594f
C21 POST_N DETECT_BLEED_3 0.06178f
C22 TERM_P_R DETECT_BLEED_3 0.27004f
C23 SUM_N_D_6 POST_TAIL_6 4.11348f
C24 TERM_ENABLE TERM_BLEED_4 0.14835f
C25 POST_BIAS DETECT_BLEED_1 0.0476f
C26 DETECT_P_I SUM_P_D_7 0.05719f
C27 POST_P TMDS_TAIL_6 0.01557f
C28 TERM_BLEED_1 TERM_N_R 0.44664f
C29 SUM_N_D_3 DETECT_P_I 0.10679f
C30 MAIN_P SUM_N_D_4 0.15877f
C31 DETECT_ENABLE_LOCAL DETECT_BLEED_1 0.11865f
C32 MAIN_TAIL_5 DETECT_ENABLE_LOCAL 0.10084f
C33 POST_TAIL_0 SUM_P_D_3 0.08096f
C34 TMDS_TAIL_2 SUM_N_D_5 0.08259f
C35 SUM_N_D_1 POST_TAIL_5 0.12471f
C36 POST_TAIL_2 SUM_P_D_5 0.08941f
C37 MAIN_BIAS POST_TAIL_0 0.04127f
C38 TERM_N_R SUM_N_D_7 0.6857f
C39 DETECT_N_I DETECT_BLEED_3 0.0931f
C40 DETECT_BLEED_6 DETECT_BLEED_1 0.00763f
C41 SUM_N_D_1 MAIN_TAIL_0 0.12259f
C42 POST_N POST_TAIL_0 5.82725f
C43 MAIN_P TMDS_TAIL_2 0.04932f
C44 POST_TAIL_0 TERM_P_R 0.55002f
C45 MAIN_TAIL_6 SUM_P_D_3 0.12054f
C46 SUM_P_D_6 MAIN_TAIL_1 0.08114f
C47 TMDS_P TMDS_TAIL_6 2.13164f
C48 POST_TAIL_2 SUM_N_D_5 0.08781f
C49 POST_P SUM_N_D_4 0.19979f
C50 MAIN_BIAS MAIN_TAIL_6 25.5778f
C51 TMDS_BIAS SUM_P_D_3 0.2728f
C52 TERM_VCM TERM_N_R 20.3761f
C53 MAIN_TAIL_1 SUM_N_D_2 0.08414f
C54 MAIN_TAIL_5 MAIN_N 0.82171f
C55 TERM_ENABLE_B TERM_BLEED_0 0.03002f
C56 DETECT_ENABLE DETECT_BLEED_3 0.20501f
C57 MAIN_N DETECT_BLEED_1 0.06178f
C58 TMDS_TAIL_6 SUM_P_D_6 1.94795f
C59 MAIN_BIAS TMDS_BIAS 0.07271f
C60 MAIN_TAIL_6 TERM_P_R 1.1553f
C61 POST_TAIL_0 DETECT_N_I 0.09246f
C62 SUM_P_D_1 POST_TAIL_7 0.08739f
C63 CASCODE PAD_P 68.872f
C64 POST_BIAS DETECT_ENABLE_LOCAL 0.55762f
C65 TMDS_BIAS POST_N 0.13588f
C66 POST_TAIL_2 MAIN_P 0.04932f
C67 VDD TERM_N_R 1.17611f
C68 MAIN_TAIL_4 DETECT_P_I 0.07871f
C69 SUM_N_D_6 MAIN_TAIL_1 0.08188f
C70 MAIN_TAIL_2 SUM_P_D_1 0.09209f
C71 TMDS_BIAS TERM_P_R 3.55877f
C72 TMDS_TAIL_5 DETECT_P_I 0.03087f
C73 SUM_P_D_2 SUM_P_D_5 0.13226f
C74 POST_P TMDS_TAIL_2 0.11955f
C75 TMDS_TAIL_7 SUM_P_D_7 1.96124f
C76 CASCODE SUM_P_D_3 7.02218f
C77 TMDS_P SUM_N_D_4 0.07003f
C78 POST_BIAS DETECT_BLEED_6 0.0479f
C79 MAIN_TAIL_6 DETECT_N_I 0.04845f
C80 TMDS_TAIL_6 SUM_N_D_6 2.3304f
C81 MAIN_TAIL_3 SUM_N_D_4 0.08781f
C82 MAIN_BIAS CASCODE 0.00803f
C83 SUM_N_D_4 TMDS_TAIL_4 2.29741f
C84 DETECT_BLEED_6 DETECT_ENABLE_LOCAL 0.01354f
C85 VDD DETECT_BLEED_4 0.00523f
C86 SUM_P_D_5 POST_TAIL_4 0.11684f
C87 POST_TAIL_1 SUM_P_D_7 0.14535f
C88 SUM_P_D_4 SUM_P_D_7 0.09661f
C89 SUM_N_D_4 SUM_P_D_6 0.04311f
C90 TMDS_BIAS DETECT_N_I 0.12641f
C91 SUM_P_D_2 SUM_N_D_5 0.09199f
C92 TMDS_BIAS TMDS_N 59.5663f
C93 POST_TAIL_1 SUM_N_D_3 0.0876f
C94 SUM_P_D_4 SUM_N_D_3 0.09773f
C95 SUM_N_D_4 SUM_N_D_2 0.18372f
C96 POST_TAIL_2 POST_P 1.43126f
C97 CASCODE TERM_P_R 0.00438f
C98 POST_TAIL_0 SUM_N_D_0 3.80237f
C99 POST_BIAS MAIN_N 0.13515f
C100 TMDS_P TMDS_TAIL_2 5.58326f
C101 MAIN_N DETECT_ENABLE_LOCAL 0.11898f
C102 SUM_N_D_5 POST_TAIL_4 0.11975f
C103 ESD_RAIL a_45878_132105# 0.53942f
C104 TMDS_BIAS DETECT_ENABLE 0.04696f
C105 MAIN_P SUM_P_D_2 1.04629f
C106 SUM_N_D_4 SUM_N_D_6 0.09082f
C107 MAIN_TAIL_5 SUM_P_D_3 0.11671f
C108 POST_BIAS DETECT_ENABLE_B 0.18318f
C109 SUM_P_D_6 TMDS_TAIL_2 0.08753f
C110 SUM_P_D_1 POST_TAIL_3 0.09024f
C111 MAIN_TAIL_6 SUM_N_D_0 0.23893f
C112 MAIN_N DETECT_BLEED_6 0.03478f
C113 TMDS_TAIL_2 SUM_N_D_2 2.04279f
C114 CASCODE DETECT_N_I 1.84348f
C115 DETECT_ENABLE_LOCAL DETECT_ENABLE_B 23.9744f
C116 MAIN_TAIL_7 POST_TAIL_0 0.32974f
C117 MAIN_BIAS DETECT_BLEED_1 0.06178f
C118 MAIN_BIAS MAIN_TAIL_5 34.6895f
C119 MAIN_P POST_TAIL_4 0.03743f
C120 TMDS_BIAS SUM_N_D_0 0.03762f
C121 TMDS_P TERM_BLEED_0 0.10464f
C122 TERM_BLEED_4 TERM_BLEED_1 0
C123 TMDS_TAIL_7 TMDS_TAIL_5 0.00305f
C124 POST_N DETECT_BLEED_1 0.03633f
C125 MAIN_TAIL_5 TERM_P_R 1.08962f
C126 TMDS_TAIL_2 SUM_N_D_6 0.08259f
C127 SUM_P_D_1 DETECT_P_I 0.02846f
C128 CASCODE DETECT_ENABLE 2.30039f
C129 POST_TAIL_2 SUM_P_D_6 0.08982f
C130 MAIN_TAIL_6 MAIN_TAIL_7 0
C131 POST_P SUM_P_D_2 0.39527f
C132 MAIN_TAIL_4 SUM_P_D_4 1.97506f
C133 POST_TAIL_2 SUM_N_D_2 1.80779f
C134 TMDS_TAIL_0 POST_TAIL_7 0.07393f
C135 SUM_N_D_4 POST_TAIL_6 0.12207f
C136 CASCODE SUM_N_D_0 2.70162f
C137 PAD_P DETECT_ENABLE_LOCAL 6.68927f
C138 SUM_P_D_5 POST_TAIL_5 1.90342f
C139 MAIN_N DETECT_ENABLE_B 0.13112f
C140 POST_P POST_TAIL_4 3.71707f
C141 DETECT_N_I DETECT_BLEED_1 0.0931f
C142 MAIN_TAIL_5 DETECT_N_I 0.04845f
C143 POST_BIAS SUM_P_D_3 0.59657f
C144 SUM_P_D_5 MAIN_TAIL_0 0.11804f
C145 POST_TAIL_2 SUM_N_D_6 0.08781f
C146 SUM_P_D_3 DETECT_ENABLE_LOCAL 0.04808f
C147 MAIN_BIAS POST_BIAS 0.14181f
C148 TMDS_P SUM_P_D_2 1.2032f
C149 SUM_P_D_0 POST_TAIL_7 0.08739f
C150 POST_BIAS TERM_BLEED_3 0.04524f
C151 POST_TAIL_5 SUM_N_D_5 2.54302f
C152 POST_BIAS POST_N 95.3095f
C153 MAIN_BIAS DETECT_ENABLE_LOCAL 0.44652f
C154 MAIN_TAIL_3 SUM_P_D_2 0.10338f
C155 MAIN_TAIL_2 SUM_P_D_0 0.08577f
C156 DETECT_ENABLE DETECT_BLEED_1 0.17133f
C157 POST_BIAS TERM_P_R 5.68269f
C158 POST_N DETECT_ENABLE_LOCAL 0.11716f
C159 a_33005_132945# a_33005_131545# 0
C160 SUM_N_D_5 MAIN_TAIL_0 0.1191f
C161 TERM_P_R DETECT_ENABLE_LOCAL 0.81927f
C162 SUM_P_D_2 SUM_P_D_6 0.02608f
C163 MAIN_BIAS DETECT_BLEED_6 0.0351f
C164 POST_TAIL_0 SUM_N_D_7 0.08169f
C165 MAIN_TAIL_5 SUM_N_D_0 0.1785f
C166 SUM_P_D_2 SUM_N_D_2 0.33326f
C167 PAD_N CASCODE 82.01421f
C168 MAIN_P POST_TAIL_5 0.03743f
C169 POST_BIAS TERM_ENABLE 0.03797f
C170 POST_N DETECT_BLEED_6 0.03451f
C171 MAIN_N SUM_P_D_3 0.21902f
C172 SUM_P_D_6 POST_TAIL_4 0.11688f
C173 DETECT_BLEED_6 TERM_P_R 0.45286f
C174 MAIN_P MAIN_TAIL_0 9.00191f
C175 POST_BIAS DETECT_N_I 0.24811f
C176 MAIN_P DETECT_PBIAS 0.09256f
C177 TMDS_BIAS TERM_BLEED_1 0.04811f
C178 POST_BIAS TMDS_N 0.08281f
C179 MAIN_P TERM_BLEED_2 0.03773f
C180 MAIN_BIAS MAIN_N 0.1324p
C181 SUM_N_D_4 MAIN_TAIL_1 0.08256f
C182 SUM_N_D_2 POST_TAIL_4 0.11699f
C183 SUM_P_D_2 SUM_N_D_6 0.14293f
C184 DETECT_ENABLE_LOCAL DETECT_N_I 0.11091p
C185 a_33005_131545# a_33005_132385# 0
C186 MAIN_TAIL_6 SUM_N_D_7 0.12126f
C187 TMDS_N DETECT_ENABLE_LOCAL 0.1164f
C188 POST_TAIL_1 SUM_P_D_1 1.81457f
C189 SUM_P_D_4 SUM_P_D_1 0.17157f
C190 MAIN_N POST_N 0.02438f
C191 SUM_N_D_1 SUM_P_D_7 0.17073f
C192 TMDS_BIAS SUM_N_D_7 0.25838f
C193 m2_34279_124800# a_33005_131545# 0.05457f
C194 SUM_N_D_1 SUM_N_D_3 0.17357f
C195 MAIN_N TERM_P_R 1.32607f
C196 POST_BIAS DETECT_ENABLE 0.08856f
C197 DETECT_BLEED_6 DETECT_N_I 0.06328f
C198 POST_P POST_TAIL_5 7.45137f
C199 TMDS_N DETECT_BLEED_6 0.03451f
C200 SUM_P_D_0 POST_TAIL_3 0.09024f
C201 MAIN_BIAS DETECT_ENABLE_B 0.13112f
C202 SUM_N_D_6 POST_TAIL_4 0.11671f
C203 TMDS_TAIL_0 DETECT_P_I 0.07832f
C204 DETECT_ENABLE DETECT_ENABLE_LOCAL 3.03572f
C205 POST_N DETECT_ENABLE_B 0.12961f
C206 CASCODE TERM_BLEED_1 0.02079f
C207 POST_P DETECT_PBIAS 0.06869f
C208 POST_P TERM_BLEED_2 0.07928f
C209 POST_BIAS SUM_N_D_0 0.85671f
C210 TERM_BLEED_5 TERM_BLEED_6 1.43318f
C211 TMDS_BIAS TERM_VCM 10.4837f
C212 TERM_P_R DETECT_ENABLE_B 1.1303f
C213 TMDS_TAIL_3 DETECT_P_I 0.03087f
C214 MAIN_N DETECT_N_I 0.0752f
C215 SUM_P_D_2 POST_TAIL_6 0.1179f
C216 SUM_N_D_0 DETECT_ENABLE_LOCAL 0.07486f
C217 MAIN_N TMDS_N 0.0242f
C218 DETECT_ENABLE DETECT_BLEED_6 1.6794f
C219 CASCODE SUM_N_D_7 2.08312f
C220 SUM_P_D_0 DETECT_P_I 0.02846f
C221 PAD_P SUM_P_D_3 2.63284f
C222 DETECT_BLEED_4 DETECT_BLEED_2 0.12309f
C223 TMDS_BIAS VDD 0.38711f
C224 MAIN_BIAS PAD_P 0.00674f
C225 DETECT_ENABLE_B DETECT_N_I 0.15682f
C226 TMDS_N DETECT_ENABLE_B 0.0826f
C227 MAIN_N DETECT_ENABLE 0.06178f
C228 POST_BIAS MAIN_TAIL_7 0.00212f
C229 CASCODE TERM_VCM 0.03684f
C230 SUM_P_D_6 POST_TAIL_5 0.12081f
C231 PAD_P TERM_P_R 2.87086f
C232 MAIN_BIAS SUM_P_D_3 0.61507f
C233 MAIN_TAIL_4 SUM_N_D_1 0.09035f
C234 SUM_N_D_2 POST_TAIL_5 0.1231f
C235 SUM_N_D_4 TMDS_TAIL_2 0.08259f
C236 SUM_P_D_6 MAIN_TAIL_0 0.11808f
C237 POST_N SUM_P_D_3 0.20627f
C238 MAIN_N SUM_N_D_0 7.04476f
C239 DETECT_ENABLE DETECT_ENABLE_B 15.8387f
C240 SUM_N_D_2 MAIN_TAIL_0 0.12108f
C241 TERM_P_R SUM_P_D_3 0.66692f
C242 POST_TAIL_7 TERM_N_R 0.82675f
C243 PAD_N DETECT_ENABLE_LOCAL 6.10046f
C244 MAIN_BIAS POST_N 0.02423f
C245 MAIN_TAIL_5 SUM_N_D_7 0.11671f
C246 TERM_ENABLE_LOCAL TERM_N_R 43.0044f
C247 PAD_P DETECT_N_I 0.55053f
C248 POST_N TERM_BLEED_3 0.03477f
C249 MAIN_BIAS TERM_P_R 6.19721f
C250 MAIN_TAIL_2 TERM_N_R 0.69813f
C251 SUM_N_D_6 POST_TAIL_5 0.12146f
C252 TERM_P_R TERM_BLEED_3 0.00257f
C253 SUM_N_D_6 MAIN_TAIL_0 0.11882f
C254 a_33005_133505# a_33005_134065# 0.0346f
C255 POST_N TERM_P_R 1.34869f
C256 SUM_P_D_4 TMDS_TAIL_0 0.08296f
C257 POST_TAIL_2 SUM_N_D_4 0.08781f
C258 SUM_P_D_2 MAIN_TAIL_1 0.08096f
C259 MAIN_N MAIN_TAIL_7 10.1893f
C260 SUM_P_D_3 DETECT_N_I 0.03089f
C261 TMDS_N SUM_P_D_3 0.51616f
C262 TERM_ENABLE TERM_BLEED_3 0.10387f
C263 ESD_RAIL a_33684_148611# 1.21921p
C264 MAIN_BIAS DETECT_N_I 0.22056f
C265 TMDS_TAIL_1 SUM_P_D_7 0.02205f
C266 MAIN_BIAS TMDS_N 0.02423f
C267 POST_BIAS TERM_BLEED_1 0.04828f
C268 TERM_ENABLE POST_N 0.02471f
C269 SUM_P_D_4 TMDS_TAIL_3 0.03645f
C270 TERM_ENABLE TERM_P_R 0.20222f
C271 POST_N DETECT_N_I 0.06617f
C272 POST_N TMDS_N 0.05152f
C273 POST_TAIL_1 SUM_P_D_0 0.09198f
C274 SUM_P_D_4 SUM_P_D_0 0.13522f
C275 TERM_P_R DETECT_N_I 0.17682f
C276 POST_TAIL_6 POST_TAIL_5 0.00785f
C277 PAD_P SUM_N_D_0 1.36433f
C278 TMDS_N TERM_P_R 2.36267f
C279 POST_BIAS SUM_N_D_7 0.55468f
C280 MAIN_BIAS DETECT_ENABLE 0.06178f
C281 DETECT_BLEED_6 TERM_BLEED_1 0.00637f
C282 SUM_N_D_7 DETECT_ENABLE_LOCAL 0.09012f
C283 SUM_N_D_0 SUM_P_D_3 0.22674f
C284 DETECT_ENABLE POST_N 0.06178f
C285 TERM_N_R POST_TAIL_3 1.03641f
C286 SUM_N_D_1 SUM_P_D_1 1.53583f
C287 MAIN_P DETECT_BLEED_0 0.04239f
C288 SUM_P_D_5 SUM_P_D_7 0.08255f
C289 MAIN_BIAS SUM_N_D_0 1.06298f
C290 SUM_P_D_2 SUM_N_D_4 0.08626f
C291 DETECT_ENABLE TERM_P_R 0.30331f
C292 TMDS_N DETECT_N_I 0.04213f
C293 SUM_N_D_3 SUM_P_D_5 0.13088f
C294 POST_BIAS TERM_VCM 0.19304f
C295 POST_N SUM_N_D_0 5.28026f
C296 MAIN_N TERM_BLEED_1 0.03509f
C297 DETECT_BLEED_2 DETECT_BLEED_3 5.39879f
C298 TERM_N_R DETECT_P_I 0.1425f
C299 SUM_N_D_0 TERM_P_R 0.77216f
C300 POST_BIAS VDD 0.0908f
C301 SUM_N_D_4 POST_TAIL_4 2.32386f
C302 SUM_N_D_5 SUM_P_D_7 0.03089f
C303 MAIN_TAIL_7 SUM_P_D_3 0.1179f
C304 PAD_N PAD_P 48.8607f
C305 DETECT_ENABLE DETECT_N_I 6.19486f
C306 MAIN_N SUM_N_D_7 6.38487f
C307 DETECT_ENABLE TMDS_N 0.00895f
C308 VDD DETECT_ENABLE_LOCAL 3.49929f
C309 SUM_P_D_2 TMDS_TAIL_2 1.9266f
C310 SUM_N_D_3 SUM_N_D_5 0.13089f
C311 MAIN_BIAS MAIN_TAIL_7 16.8177f
C312 PAD_N SUM_P_D_3 1.04771f
C313 DETECT_P_I DETECT_BLEED_4 0.07445f
C314 SUM_N_D_0 DETECT_N_I 0.04428f
C315 POST_N MAIN_TAIL_7 0
C316 TMDS_N SUM_N_D_0 0.40957f
C317 MAIN_TAIL_7 TERM_P_R 1.15234f
C318 MAIN_P SUM_P_D_7 4.11612f
C319 SUM_N_D_7 DETECT_ENABLE_B 0.10581f
C320 VDD DETECT_BLEED_6 0.45519f
C321 MAIN_N TERM_VCM 0.07211f
C322 PAD_N MAIN_BIAS 0.00108f
C323 MAIN_P SUM_N_D_3 0.20861f
C324 MAIN_TAIL_1 MAIN_TAIL_0 0.02151f
C325 POST_TAIL_2 SUM_P_D_2 1.93451f
C326 MAIN_TAIL_4 SUM_P_D_5 0.09348f
C327 TERM_ENABLE_LOCAL TERM_BLEED_4 0.00103f
C328 PAD_N TERM_P_R 0.46271f
C329 SUM_P_D_5 TMDS_TAIL_5 1.94314f
C330 POST_P SUM_P_D_7 2.42465f
C331 DETECT_BLEED_5 DETECT_BLEED_0 0.10542f
C332 PAD_P SUM_N_D_7 0.8718f
C333 POST_P SUM_N_D_3 0.20799f
C334 MAIN_TAIL_4 SUM_N_D_5 0.09024f
C335 TERM_N_R TMDS_TAIL_7 0.98454f
C336 VDD DETECT_ENABLE_B 3.27294f
C337 PAD_N DETECT_N_I 0.70599f
C338 TMDS_TAIL_5 SUM_N_D_5 1.93828f
C339 MAIN_BIAS TERM_BLEED_1 0.03525f
C340 SUM_N_D_4 POST_TAIL_5 0.13002f
C341 SUM_N_D_1 TMDS_TAIL_0 0.11123f
C342 TERM_BLEED_1 TERM_BLEED_3 0.00153f
C343 SUM_N_D_7 SUM_P_D_3 0.53326f
C344 POST_N TERM_BLEED_1 0.03489f
C345 TERM_P_R TERM_BLEED_1 0.45665f
C346 TMDS_TAIL_1 SUM_P_D_1 1.83223f
C347 POST_TAIL_1 TERM_N_R 0.69813f
C348 SUM_P_D_4 TERM_N_R 0.00565f
C349 SUM_N_D_4 MAIN_TAIL_0 0.1195f
C350 MAIN_BIAS SUM_N_D_7 0.59345f
C351 MAIN_TAIL_4 MAIN_P 1.42035f
C352 MAIN_TAIL_7 SUM_N_D_0 0.23954f
C353 CASCODE DETECT_BLEED_2 0.14463f
C354 MAIN_P TMDS_TAIL_5 0.03743f
C355 TMDS_P SUM_P_D_7 3.33999f
C356 POST_N SUM_N_D_7 4.64398f
C357 TMDS_P SUM_N_D_3 0.06003f
C358 MAIN_TAIL_3 SUM_P_D_7 0.14994f
C359 SUM_N_D_1 SUM_P_D_0 0.48022f
C360 TERM_ENABLE TERM_BLEED_1 0.19416f
C361 TMDS_TAIL_4 SUM_P_D_7 0.15453f
C362 TERM_P_R SUM_N_D_7 0.75912f
C363 MAIN_TAIL_3 SUM_N_D_3 1.80736f
C364 SUM_P_D_2 POST_TAIL_4 0.11671f
C365 PAD_N SUM_N_D_0 4.17975f
C366 ESD_RAIL a_33005_132945# 0.53823f
C367 MAIN_BIAS TERM_VCM 0.07211f
C368 SUM_N_D_3 TMDS_TAIL_4 0.00164f
C369 TERM_BLEED_1 DETECT_N_I 0.06307f
C370 SUM_P_D_6 SUM_P_D_7 98.1063f
C371 TMDS_N TERM_BLEED_1 0.03472f
C372 SUM_P_D_6 SUM_N_D_3 0.02421f
C373 SUM_N_D_2 SUM_P_D_7 0.19275f
C374 TERM_VCM POST_N 0.1283f
C375 SUM_N_D_2 SUM_N_D_3 0.10014p
C376 TERM_VCM TERM_P_R 23.2128f
C377 SUM_P_D_1 SUM_P_D_5 0.20472f
C378 TMDS_BIAS POST_TAIL_7 0.10303f
C379 POST_P TMDS_TAIL_5 0.07486f
C380 SUM_N_D_7 DETECT_N_I 0.06363f
C381 TMDS_BIAS TERM_ENABLE_LOCAL 0.19254f
C382 TMDS_N SUM_N_D_7 1.07076f
C383 VDD POST_N 0.0669f
C384 DETECT_ENABLE TERM_BLEED_1 0.16899f
C385 DETECT_BLEED_2 DETECT_BLEED_1 3.8517f
C386 SUM_N_D_6 SUM_P_D_7 0.14252f
C387 ESD_RAIL a_33005_132385# 0.53823f
C388 TERM_VCM TERM_ENABLE 0.48198f
C389 SUM_N_D_6 SUM_N_D_3 0.06838f
C390 VDD TERM_P_R 2.89944f
C391 DETECT_P_I DETECT_BLEED_3 0.07445f
C392 ESD_RAIL m2_34279_124800# 5.47988f
C393 SUM_P_D_1 SUM_N_D_5 0.03638f
C394 TERM_VCM DETECT_N_I 0.23943f
C395 TERM_VCM TMDS_N 0.17315f
C396 DETECT_ENABLE SUM_N_D_7 0.08066f
C397 TERM_BLEED_2 TERM_BLEED_0 0
C398 TERM_ENABLE VDD 3.01955f
C399 TMDS_P TMDS_TAIL_5 8.59047f
C400 MAIN_TAIL_3 MAIN_TAIL_4 2.23974f
C401 VDD DETECT_N_I 3.05705f
C402 SUM_N_D_0 SUM_N_D_7 0.16816f
C403 MAIN_P SUM_P_D_1 2.78116f
C404 TMDS_TAIL_4 TMDS_TAIL_5 0.07982f
C405 VDD TMDS_N 0.29659f
C406 MAIN_TAIL_4 SUM_P_D_6 0.09024f
C407 DETECT_ENABLE TERM_VCM 0.46816f
C408 POST_TAIL_6 SUM_P_D_7 0.18732f
C409 SUM_P_D_6 TMDS_TAIL_5 0.07892f
C410 a_45878_132665# a_45878_132105# 0.0346f
C411 POST_TAIL_0 DETECT_P_I 0.07832f
C412 MAIN_TAIL_4 SUM_N_D_2 0.09032f
C413 POST_TAIL_6 SUM_N_D_3 0.12275f
C414 SUM_P_D_2 POST_TAIL_5 0.12054f
C415 TMDS_TAIL_1 TMDS_TAIL_0 0.0349f
C416 DETECT_ENABLE VDD 0.93231f
C417 POST_BIAS DETECT_BLEED_2 0.08903f
C418 SUM_P_D_2 MAIN_TAIL_0 0.1179f
C419 DETECT_ENABLE_LOCAL DETECT_BLEED_2 0.12134f
C420 MAIN_TAIL_7 SUM_N_D_7 4.07014f
C421 MAIN_TAIL_4 SUM_N_D_6 0.09024f
C422 MAIN_TAIL_6 DETECT_P_I 0.03087f
C423 POST_TAIL_5 POST_TAIL_4 0.0066f
C424 SUM_N_D_6 TMDS_TAIL_5 0.07182f
C425 POST_P SUM_P_D_1 1.12998f
C426 TMDS_BIAS DETECT_P_I 0.0916f
C427 DETECT_BLEED_6 DETECT_BLEED_2 0.00763f
C428 PAD_N SUM_N_D_7 3.28199f
C429 TMDS_TAIL_0 SUM_P_D_5 0.08296f
C430 SUM_N_D_1 TERM_N_R 1.20762f
C431 TMDS_TAIL_3 SUM_P_D_5 0.02404f
C432 TMDS_P SUM_P_D_1 0.83916f
C433 MAIN_N DETECT_BLEED_2 0.06178f
C434 CASCODE DETECT_P_I 0.01892f
C435 MAIN_TAIL_1 SUM_P_D_7 0.13897f
C436 MAIN_TAIL_3 SUM_P_D_1 0.08831f
C437 TMDS_TAIL_0 SUM_N_D_5 0.08296f
C438 MAIN_TAIL_1 SUM_N_D_3 0.08318f
C439 SUM_P_D_0 SUM_P_D_5 0.18733f
C440 POST_BIAS POST_TAIL_7 7.3911f
C441 SUM_P_D_6 SUM_P_D_1 0.09876f
C442 POST_BIAS TERM_ENABLE_LOCAL 0.18986f
C443 TMDS_TAIL_6 SUM_P_D_7 0.05905f
C444 SUM_P_D_1 SUM_N_D_2 0.08485f
C445 POST_TAIL_7 DETECT_ENABLE_LOCAL 0.08279f
C446 TMDS_TAIL_3 SUM_N_D_5 0.02404f
C447 MAIN_TAIL_2 DETECT_ENABLE_LOCAL 0.08279f
C448 POST_TAIL_1 POST_TAIL_0 2.81167f
C449 POST_TAIL_0 SUM_P_D_4 0.08105f
C450 MAIN_P TMDS_TAIL_0 0.04932f
C451 SUM_P_D_0 SUM_N_D_5 0.80634f
C452 TMDS_BIAS TMDS_TAIL_7 10.5411f
C453 SUM_N_D_6 SUM_P_D_1 0.08799f
C454 MAIN_P TMDS_TAIL_3 0.03743f
C455 DETECT_P_I DETECT_BLEED_1 0.07445f
C456 MAIN_TAIL_5 DETECT_P_I 0.03087f
C457 MAIN_TAIL_6 SUM_P_D_4 0.12062f
C458 SUM_N_D_4 SUM_P_D_7 0.08429f
C459 MAIN_P SUM_P_D_0 4.59567f
C460 VDD TERM_BLEED_1 0.46209f
C461 MAIN_N TERM_ENABLE_LOCAL 0.07261f
C462 TMDS_BIAS SUM_P_D_4 0.15808f
C463 MAIN_N POST_TAIL_7 0.03631f
C464 SUM_N_D_4 SUM_N_D_3 0.1001p
C465 POST_P TMDS_TAIL_0 0.12207f
C466 MAIN_N MAIN_TAIL_2 7.25951f
C467 a_45878_131545# a_45878_132105# 0.0346f
C468 POST_BIAS POST_TAIL_3 23.8456f
C469 MAIN_BIAS DETECT_BLEED_2 0.06178f
C470 SUM_P_D_1 POST_TAIL_6 0.1179f
C471 POST_P TMDS_TAIL_3 0.03743f
C472 TMDS_TAIL_2 SUM_P_D_7 0.2092f
C473 DETECT_ENABLE_LOCAL POST_TAIL_3 0.08279f
C474 TMDS_TAIL_6 TMDS_TAIL_5 0.03177f
C475 POST_N DETECT_BLEED_2 0.06237f
C476 TMDS_TAIL_2 SUM_N_D_3 0.0973f
C477 POST_P SUM_P_D_0 2.90421f
C478 CASCODE SUM_P_D_4 4.98592f
C479 TERM_VCM VDD 5.51563f
C480 TMDS_P TMDS_TAIL_0 7.61567f
C481 POST_BIAS DETECT_P_I 0.15266f
C482 TMDS_TAIL_1 TERM_N_R 0.27155f
C483 DETECT_ENABLE_LOCAL DETECT_P_I 8.81116f
C484 TMDS_TAIL_0 SUM_P_D_6 0.08296f
C485 TMDS_P TMDS_TAIL_3 2.80141f
C486 POST_TAIL_2 SUM_P_D_7 0.14994f
C487 DETECT_N_I DETECT_BLEED_2 0.0931f
C488 TMDS_TAIL_7 DETECT_BLEED_1 0
C489 POST_TAIL_2 SUM_N_D_3 0.08781f
C490 MAIN_TAIL_4 SUM_N_D_4 1.8568f
C491 TMDS_TAIL_0 SUM_N_D_2 0.08459f
C492 TMDS_P SUM_P_D_0 2.62794f
C493 MAIN_N POST_TAIL_3 0.03631f
C494 DETECT_BLEED_6 DETECT_P_I 0.04157f
C495 TMDS_TAIL_3 TMDS_TAIL_4 0.00767f
C496 MAIN_TAIL_3 SUM_P_D_0 0.0882f
C497 POST_TAIL_7 SUM_P_D_3 0.08739f
C498 TMDS_TAIL_3 SUM_P_D_6 0.02404f
C499 TERM_BLEED_5 TERM_BLEED_2 0.00315f
C500 MAIN_BIAS POST_TAIL_7 0.03684f
C501 TERM_N_R SUM_P_D_5 0.387f
C502 MAIN_TAIL_2 SUM_P_D_3 0.08625f
C503 MAIN_TAIL_5 SUM_P_D_4 0.22362f
C504 SUM_P_D_6 SUM_P_D_0 0.06249f
C505 DETECT_ENABLE DETECT_BLEED_2 0.18447f
C506 TMDS_TAIL_0 SUM_N_D_6 0.08296f
C507 MAIN_BIAS TERM_ENABLE_LOCAL 0.0727f
C508 SUM_P_D_0 SUM_N_D_2 0.38273f
C509 MAIN_BIAS MAIN_TAIL_2 15.8686f
C510 MAIN_N DETECT_P_I 0.06178f
C511 TERM_ENABLE_LOCAL TERM_BLEED_3 0
C512 POST_N POST_TAIL_7 5.45854f
C513 SUM_P_D_1 MAIN_TAIL_1 1.85742f
C514 POST_N TERM_ENABLE_LOCAL 0.12363f
C515 TERM_N_R TERM_BLEED_6 0.94631f
C516 TERM_P_R POST_TAIL_7 0.67108f
C517 TMDS_TAIL_3 SUM_N_D_6 0.02404f
C518 TERM_ENABLE_LOCAL TERM_P_R 25.6967f
C519 MAIN_TAIL_2 TERM_P_R 0.55676f
C520 DETECT_P_I DETECT_ENABLE_B 0.15648f
C521 SUM_P_D_0 SUM_N_D_6 1.33307f
C522 TERM_ENABLE_B TERM_N_R 0.76613f
C523 SUM_P_D_2 SUM_P_D_7 0.08962f
C524 POST_BIAS TMDS_TAIL_7 0.08819f
C525 SUM_P_D_2 SUM_N_D_3 0.14777f
C526 TERM_ENABLE TERM_ENABLE_LOCAL 7.18542f
C527 TMDS_TAIL_7 DETECT_ENABLE_LOCAL 0.11758f
C528 POST_TAIL_0 SUM_N_D_1 0.08565f
C529 POST_TAIL_7 DETECT_N_I 0.09246f
C530 TERM_ENABLE_LOCAL DETECT_N_I 0.18552f
C531 TMDS_N TERM_ENABLE_LOCAL 0.15897f
C532 SUM_P_D_7 POST_TAIL_4 0.18785f
C533 MAIN_P TERM_N_R 1.17999f
C534 MAIN_TAIL_2 DETECT_N_I 0.09284f
C535 POST_BIAS POST_TAIL_1 13.3928f
C536 POST_BIAS SUM_P_D_4 0.9098f
C537 SUM_N_D_3 POST_TAIL_4 0.28645f
C538 SUM_P_D_3 POST_TAIL_3 2.21607f
C539 SUM_P_D_4 DETECT_ENABLE_LOCAL 0.11405f
C540 MAIN_TAIL_6 SUM_N_D_1 0.1244f
C541 POST_TAIL_1 DETECT_ENABLE_LOCAL 0.08279f
C542 PAD_P DETECT_P_I 0.66977f
C543 SUM_N_D_4 SUM_P_D_1 0.02967f
C544 MAIN_BIAS POST_TAIL_3 0.03684f
C545 DETECT_ENABLE TERM_ENABLE_LOCAL 0.08832f
C546 SUM_P_D_0 POST_TAIL_6 0.1179f
C547 TMDS_BIAS SUM_N_D_1 0.12405f
C548 MAIN_P DETECT_BLEED_4 0.08856f
C549 POST_N POST_TAIL_3 0.53883f
C550 MAIN_N TMDS_TAIL_7 0.03631f
C551 TERM_P_R POST_TAIL_3 1.09162f
C552 SUM_N_D_0 POST_TAIL_7 4.02272f
C553 SUM_P_D_3 DETECT_P_I 0.02846f
C554 POST_P TERM_N_R 1.26272f
C555 MAIN_BIAS DETECT_P_I 0.12833p
C556 MAIN_TAIL_2 SUM_N_D_0 0.18921f
C557 MAIN_TAIL_4 SUM_P_D_2 0.09024f
C558 TMDS_TAIL_7 DETECT_ENABLE_B 0.75436f
C559 POST_N DETECT_P_I 0.03053f
C560 MAIN_N POST_TAIL_1 0.03631f
C561 MAIN_N SUM_P_D_4 0.31215f
C562 CASCODE SUM_N_D_1 10.3854f
C563 TERM_P_R DETECT_P_I 0.12332f
C564 POST_P DETECT_BLEED_4 0.08856f
C565 DETECT_N_I POST_TAIL_3 0.09246f
C566 TMDS_P TERM_N_R 1.95079f
C567 a_33005_131825# a_33005_132385# 0.0346f
C568 POST_TAIL_2 SUM_P_D_1 0.10322f
C569 POST_TAIL_5 SUM_P_D_7 0.19082f
C570 MAIN_TAIL_3 TERM_N_R 0.72984f
C571 m2_34279_124800# a_33005_131825# 0
C572 TERM_N_R TMDS_TAIL_4 0.81244f
C573 DETECT_P_I DETECT_N_I 47.0863f
C574 SUM_N_D_3 POST_TAIL_5 0.12207f
C575 TMDS_N DETECT_P_I 0.03053f
C576 SUM_P_D_7 MAIN_TAIL_0 0.18775f
C577 SUM_P_D_6 TERM_N_R 1.1859f
C578 SUM_N_D_3 MAIN_TAIL_0 0.12012f
C579 TERM_N_R DETECT_BLEED_5 0.77399f
C580 SUM_P_D_0 MAIN_TAIL_1 0.08096f
C581 TMDS_P DETECT_BLEED_4 0.05062f
C582 SUM_N_D_2 TERM_N_R 0.27547f
C583 SUM_N_D_0 POST_TAIL_3 0.70616f
C584 MAIN_TAIL_5 SUM_N_D_1 0.11671f
C585 TERM_BLEED_4 TERM_BLEED_6 0.00201f
C586 PAD_P SUM_P_D_4 1.81289f
C587 DETECT_ENABLE DETECT_P_I 0.07465f
C588 DETECT_BLEED_5 DETECT_BLEED_4 8.48601f
C589 MAIN_BIAS TMDS_TAIL_7 0.03684f
C590 SUM_N_D_6 TERM_N_R 0.95205f
C591 TMDS_TAIL_0 SUM_N_D_4 0.08296f
C592 POST_N TMDS_TAIL_7 0.06234f
C593 SUM_N_D_0 DETECT_P_I 0.04185f
C594 POST_TAIL_1 SUM_P_D_3 0.08625f
C595 SUM_P_D_4 SUM_P_D_3 98.0611f
C596 TERM_P_R TMDS_TAIL_7 0.98454f
C597 TERM_ENABLE_LOCAL TERM_BLEED_1 0.0568f
C598 ESD_RAIL a_33005_134065# 0.57348f
C599 SUM_P_D_2 SUM_P_D_1 98.0904f
C600 TMDS_TAIL_3 SUM_N_D_4 0.03793f
C601 MAIN_BIAS POST_TAIL_1 0.03684f
C602 MAIN_BIAS SUM_P_D_4 0.72459f
C603 TMDS_BIAS TMDS_TAIL_1 4.86564f
C604 POST_TAIL_0 SUM_P_D_5 0.0811f
C605 POST_N SUM_P_D_4 0.16481f
C606 SUM_N_D_4 SUM_P_D_0 0.47794f
C607 POST_TAIL_7 SUM_N_D_7 3.1134f
C608 TMDS_TAIL_0 TMDS_TAIL_2 0.0061f
C609 POST_TAIL_1 POST_N 4.18635f
C610 SUM_P_D_1 POST_TAIL_4 0.11671f
C611 POST_TAIL_1 TERM_P_R 0.55676f
C612 SUM_P_D_4 TERM_P_R 0.03472f
C613 MAIN_TAIL_2 SUM_N_D_7 0.08637f
C614 TMDS_TAIL_7 DETECT_N_I 0.08577f
C615 MAIN_P DETECT_BLEED_3 0.08856f
C616 POST_BIAS SUM_N_D_1 0.57748f
C617 POST_TAIL_6 TERM_N_R 1.06959f
C618 ESD_RAIL PAD_P 24.1165f
C619 TMDS_N TMDS_TAIL_7 4.85889f
C620 MAIN_TAIL_6 SUM_P_D_5 0.12128f
C621 SUM_N_D_1 DETECT_ENABLE_LOCAL 0.04808f
C622 TMDS_TAIL_3 TMDS_TAIL_2 0.03876f
C623 POST_TAIL_0 SUM_N_D_5 0.08216f
C624 TERM_VCM TERM_ENABLE_LOCAL 47.624f
C625 POST_P TERM_BLEED_4 0.00395f
C626 SUM_P_D_0 TMDS_TAIL_2 0.00305f
C627 PAD_N DETECT_P_I 3.08441f
C628 TMDS_BIAS SUM_P_D_5 0.14871f
C629 POST_TAIL_1 DETECT_N_I 0.09246f
C630 SUM_P_D_4 DETECT_N_I 0.12335f
C631 TMDS_N SUM_P_D_4 0.07817f
C632 DETECT_ENABLE TMDS_TAIL_7 0.2578f
C633 VDD TERM_ENABLE_LOCAL 3.83248f
C634 POST_P DETECT_BLEED_3 0.08856f
C635 MAIN_TAIL_6 SUM_N_D_5 0.34112f
C636 TMDS_BIAS TERM_BLEED_6 0.05286f
C637 MAIN_P POST_TAIL_0 0.04868f
C638 TMDS_BIAS SUM_N_D_5 0.17886f
C639 MAIN_N SUM_N_D_1 5.12924f
C640 POST_TAIL_2 SUM_P_D_0 0.0882f
C641 CASCODE SUM_P_D_5 2.19278f
C642 SUM_N_D_7 POST_TAIL_3 0.09024f
C643 MAIN_P MAIN_TAIL_6 9.58589f
C644 POST_TAIL_1 SUM_N_D_0 0.64965f
C645 SUM_N_D_0 SUM_P_D_4 0.15321f
C646 TERM_BLEED_1 DETECT_P_I 0.04165f
C647 POST_P POST_TAIL_0 4.9968f
C648 TMDS_BIAS MAIN_P 0.11273f
C649 SUM_P_D_1 POST_TAIL_5 0.12054f
C650 MAIN_TAIL_1 TERM_N_R 0.7096f
C651 SUM_P_D_2 TMDS_TAIL_0 0.08296f
C652 CASCODE SUM_N_D_5 7.5198f
C653 SUM_N_D_7 DETECT_P_I 0.03651f
C654 SUM_P_D_1 MAIN_TAIL_0 0.1179f
C655 DETECT_BLEED_5 DETECT_BLEED_3 0.10633f
C656 TMDS_TAIL_6 TERM_N_R 0.55873f
C657 MAIN_TAIL_7 SUM_P_D_4 0.11799f
C658 MAIN_TAIL_5 SUM_P_D_5 2.37931f
C659 TERM_VCM DETECT_P_I 0.09422f
C660 TMDS_BIAS POST_P 0.26313f
C661 PAD_P SUM_N_D_1 1.82682f
C662 SUM_P_D_2 SUM_P_D_0 0.13914f
C663 ESD_RAIL a_33005_133505# 0.53842f
C664 ESD_RAIL a_45878_134345# 0.5677f
C665 PAD_N SUM_P_D_4 2.35993f
C666 SUM_P_D_0 POST_TAIL_4 0.11671f
C667 SUM_N_D_1 SUM_P_D_3 0.19593f
C668 POST_TAIL_0 SUM_P_D_6 0.08114f
C669 VDD DETECT_P_I 1.25973f
C670 MAIN_TAIL_5 SUM_N_D_5 1.93858f
C671 SUM_N_D_4 TERM_N_R 0.45971f
C672 MAIN_BIAS SUM_N_D_1 0.60913f
C673 POST_TAIL_0 SUM_N_D_2 0.08414f
C674 ESD_RAIL a_45878_133225# 0.53916f
C675 a_35813_117064# a_33005_131545# 2.2693f
C676 POST_N SUM_N_D_1 3.40034f
C677 TMDS_BIAS TMDS_P 1.31179f
C678 SUM_N_D_1 TERM_P_R 1.39643f
C679 MAIN_TAIL_6 SUM_P_D_6 1.90346f
C680 MAIN_P DETECT_BLEED_1 0.08856f
C681 MAIN_TAIL_5 MAIN_P 1.32062f
C682 POST_TAIL_0 SUM_N_D_6 0.08188f
C683 TMDS_BIAS TMDS_TAIL_4 11.7441f
C684 SUM_N_D_7 TMDS_TAIL_7 1.94964f
C685 POST_BIAS SUM_P_D_5 1.95824f
C686 TMDS_TAIL_2 TERM_N_R 1.24011f
C687 MAIN_TAIL_6 SUM_N_D_2 0.1229f
C688 SUM_N_D_3 SUM_P_D_7 0.08857f
C689 SUM_P_D_5 DETECT_ENABLE_LOCAL 0.18003f
C690 PAD_N ESD_RAIL 22.9384f
C691 TMDS_BIAS SUM_P_D_6 0.20068f
C692 TMDS_BIAS DETECT_BLEED_5 0.09283f
C693 TMDS_BIAS SUM_N_D_2 0.10352f
C694 SUM_N_D_1 DETECT_N_I 0.03089f
C695 SUM_P_D_4 SUM_N_D_7 0.54261f
C696 MAIN_TAIL_6 SUM_N_D_6 3.01208f
C697 TMDS_N SUM_N_D_1 2.67149f
C698 POST_TAIL_1 SUM_N_D_7 0.08637f
C699 POST_BIAS SUM_N_D_5 0.6467f
C700 POST_BIAS TERM_ENABLE_B 0.04185f
C701 POST_P DETECT_BLEED_1 0.07065f
C702 DETECT_ENABLE_LOCAL SUM_N_D_5 0.11405f
C703 POST_TAIL_2 TERM_N_R 0.72984f
C704 TMDS_BIAS SUM_N_D_6 0.26137f
C705 CASCODE SUM_P_D_6 7.98913f
C706 TERM_N_R TERM_BLEED_0 0.75396f
C707 VDD TMDS_TAIL_7 0.00881f
C708 CASCODE DETECT_BLEED_5 0.06639f
C709 CASCODE SUM_N_D_2 2.82646f
C710 MAIN_N SUM_P_D_5 0.20809f
C711 POST_BIAS MAIN_P 0.18788f
C712 SUM_P_D_0 POST_TAIL_5 0.12054f
C713 MAIN_P DETECT_ENABLE_LOCAL 0.14524f
C714 SUM_P_D_0 MAIN_TAIL_0 1.8809f
C715 SUM_N_D_0 SUM_N_D_1 0.10008p
C716 CASCODE SUM_N_D_6 5.78089f
C717 TMDS_P DETECT_BLEED_1 0
C718 MAIN_TAIL_4 SUM_P_D_7 0.13042f
C719 MAIN_TAIL_4 SUM_N_D_3 0.19684f
C720 TMDS_TAIL_5 SUM_P_D_7 0.07486f
C721 MAIN_N SUM_N_D_5 0.38097f
C722 TMDS_BIAS POST_TAIL_6 0
C723 MAIN_P DETECT_BLEED_6 0.04807f
C724 MAIN_TAIL_5 SUM_P_D_6 0.11688f
C725 POST_BIAS POST_P 3.67363f
C726 DETECT_BLEED_5 DETECT_BLEED_1 0.10542f
C727 SUM_P_D_2 TERM_N_R 0.00741f
C728 MAIN_TAIL_5 SUM_N_D_2 0.11671f
C729 MAIN_TAIL_7 SUM_N_D_1 0.12501f
C730 POST_P DETECT_ENABLE_LOCAL 0.14395f
C731 MAIN_N MAIN_P 0.13162p
C732 TERM_N_R POST_TAIL_4 1.04845f
C733 PAD_P SUM_P_D_5 3.75513f
C734 TMDS_TAIL_1 TERM_P_R 0.49496f
C735 MAIN_TAIL_5 SUM_N_D_6 0.11768f
C736 POST_P DETECT_BLEED_6 0.0479f
C737 PAD_N SUM_N_D_1 1.98361f
C738 MAIN_P DETECT_ENABLE_B 0.18469f
C739 SUM_P_D_5 SUM_P_D_3 0.15516f
C740 POST_BIAS TMDS_P 0.11893f
C741 TMDS_P DETECT_ENABLE_LOCAL 0.14557f
C742 MAIN_BIAS SUM_P_D_5 1.35428f
C743 PAD_P SUM_N_D_5 0.51025f
C744 POST_BIAS TMDS_TAIL_4 0.03743f
C745 MAIN_N POST_P 0.02437f
C746 MAIN_TAIL_3 DETECT_ENABLE_LOCAL 0.08279f
C747 POST_BIAS SUM_P_D_6 1.25181f
C748 TMDS_N TMDS_TAIL_1 2.31305f
C749 POST_BIAS DETECT_BLEED_5 0.08856f
C750 POST_N SUM_P_D_5 0.16017f
C751 POST_BIAS SUM_N_D_2 0.58509f
C752 TMDS_P DETECT_BLEED_6 0.0479f
C753 TERM_P_R SUM_P_D_5 0.42172f
C754 DETECT_BLEED_5 DETECT_ENABLE_LOCAL 0.11177f
C755 SUM_P_D_6 DETECT_ENABLE_LOCAL 0.04808f
C756 SUM_P_D_3 SUM_N_D_5 0.09791f
C757 SUM_P_D_1 SUM_P_D_7 0.18658f
C758 POST_P DETECT_ENABLE_B 0.18318f
C759 SUM_N_D_2 DETECT_ENABLE_LOCAL 0.04808f
C760 SUM_P_D_1 SUM_N_D_3 0.05321f
C761 MAIN_BIAS SUM_N_D_5 0.82951f
C762 TMDS_BIAS TMDS_TAIL_6 8.36357f
C763 TERM_P_R TERM_BLEED_6 1.51739f
C764 POST_BIAS SUM_N_D_6 0.56557f
C765 DETECT_BLEED_6 DETECT_BLEED_5 9.99211f
C766 POST_TAIL_0 SUM_N_D_4 0.08256f
C767 MAIN_N TMDS_P 0.0242f
C768 DETECT_P_I DETECT_BLEED_2 0.07445f
C769 POST_N SUM_N_D_5 3.02401f
C770 a_34245_90628# a_33005_131545# 0.0135f
C771 POST_N TERM_ENABLE_B 0.02846f
C772 MAIN_P SUM_P_D_3 0.3706f
C773 SUM_P_D_5 DETECT_N_I 0.21581f
C774 SUM_N_D_1 SUM_N_D_7 0.1775f
C775 TERM_P_R SUM_N_D_5 0.03472f
C776 SUM_N_D_6 DETECT_ENABLE_LOCAL 0.11405f
C777 MAIN_N MAIN_TAIL_3 5.2647f
C778 TERM_ENABLE_B TERM_P_R 0.26594f
C779 TMDS_N SUM_P_D_5 0.07041f
C780 MAIN_BIAS MAIN_P 7.31683f
C781 TERM_ENABLE TERM_BLEED_6 0.87291f
C782 TERM_N_R POST_TAIL_5 1.11782f
C783 MAIN_N SUM_P_D_6 0.12708f
C784 MAIN_N DETECT_BLEED_5 0.06178f
C785 TMDS_P DETECT_ENABLE_B 0.11489f
C786 MAIN_TAIL_6 SUM_N_D_4 0.12132f
C787 TMDS_N TERM_BLEED_6 0.04055f
C788 MAIN_P POST_N 0.04129f
C789 TERM_ENABLE TERM_ENABLE_B 8.21683f
C790 MAIN_N SUM_N_D_2 3.31535f
C791 DETECT_PBIAS TERM_N_R 0.09723f
C792 MAIN_P TERM_P_R 1.32436f
C793 TERM_N_R MAIN_TAIL_0 1.06974f
C794 TMDS_BIAS SUM_N_D_4 0.17053f
C795 SUM_N_D_5 DETECT_N_I 0.12335f
C796 TMDS_N SUM_N_D_5 2.46314f
C797 a_35813_117064# a_34245_90628# 0.00994f
C798 POST_BIAS POST_TAIL_6 8.73618f
C799 POST_P SUM_P_D_3 1.48305f
C800 MAIN_TAIL_4 SUM_P_D_1 0.09024f
C801 SUM_N_D_0 SUM_P_D_5 0.2224f
C802 MAIN_N SUM_N_D_6 0.71389f
C803 MAIN_BIAS POST_P 0.02948f
C804 MAIN_P DETECT_N_I 0.08783f
C805 POST_P TERM_BLEED_3 0.08265f
C806 POST_P POST_N 94.8168f
C807 MAIN_P TMDS_N 0.03757f
C808 TMDS_BIAS TMDS_TAIL_2 14.9026f
C809 CASCODE SUM_N_D_4 3.93831f
C810 POST_TAIL_7 DETECT_P_I 0.07832f
C811 POST_P TERM_P_R 1.60403f
C812 TERM_ENABLE_LOCAL DETECT_P_I 0.09251f
C813 MAIN_TAIL_2 DETECT_P_I 0.07903f
C814 SUM_N_D_0 SUM_N_D_5 0.19684f
C815 TMDS_P SUM_P_D_3 2.62262f
C816 PAD_P SUM_P_D_6 1.78533f
C817 MAIN_TAIL_7 SUM_P_D_5 0.11804f
C818 DETECT_ENABLE MAIN_P 0.08856f
C819 MAIN_TAIL_3 SUM_P_D_3 1.91994f
C820 POST_P TERM_ENABLE 0.04601f
C821 TMDS_TAIL_0 SUM_P_D_7 0.12619f
C822 MAIN_BIAS TMDS_P 0.02423f
C823 PAD_P SUM_N_D_2 1.25516f
C824 TMDS_TAIL_0 SUM_N_D_3 0.08296f
C825 POST_P DETECT_N_I 0.08495f
C826 MAIN_BIAS MAIN_TAIL_3 23.0839f
C827 SUM_P_D_6 SUM_P_D_3 0.04874f
C828 TMDS_P POST_N 0.07755f
C829 TMDS_BIAS TERM_BLEED_0 0.09207f
C830 POST_P TMDS_N 0.10034f
C831 MAIN_P SUM_N_D_0 0.32655f
C832 PAD_N SUM_P_D_5 0.84187f
C833 SUM_N_D_2 SUM_P_D_3 0.21074f
C834 TMDS_P TERM_P_R 2.42032f
C835 TMDS_TAIL_3 SUM_P_D_7 0.03743f
C836 a_45878_133785# a_45878_134345# 0.0346f
C837 TERM_BLEED_5 TERM_N_R 0.38957f
C838 MAIN_BIAS SUM_P_D_6 1.91915f
C839 PAD_P SUM_N_D_6 2.79182f
C840 POST_N TMDS_TAIL_4 0.02404f
C841 MAIN_TAIL_7 SUM_N_D_5 0.12153f
C842 MAIN_BIAS DETECT_BLEED_5 0.06178f
C843 MAIN_TAIL_3 TERM_P_R 0.76819f
C844 TMDS_TAIL_3 SUM_N_D_3 1.94257f
C845 MAIN_BIAS SUM_N_D_2 0.60449f
C846 POST_TAIL_0 SUM_P_D_2 0.08096f
C847 TERM_P_R TMDS_TAIL_4 1.36005f
C848 MAIN_TAIL_5 SUM_N_D_4 0.26345f
C849 POST_N DETECT_BLEED_5 0.06178f
C850 POST_N SUM_P_D_6 0.132f
C851 ESD_RAIL a_33005_131545# 96.5489f
C852 SUM_P_D_0 SUM_P_D_7 0.11841f
C853 PAD_N ATB_ESD_RAIL 0.01183f
C854 DETECT_ENABLE POST_P 0.08856f
C855 MAIN_TAIL_1 DETECT_ENABLE_LOCAL 0.08317f
C856 SUM_P_D_0 SUM_N_D_3 0.5023f
C857 POST_N SUM_N_D_2 1.66286f
C858 SUM_P_D_6 TERM_P_R 1.10896f
C859 SUM_N_D_6 SUM_P_D_3 0.14925f
C860 TERM_P_R DETECT_BLEED_5 0.77399f
C861 PAD_N SUM_N_D_5 2.72992f
C862 TERM_P_R SUM_N_D_2 0.41287f
C863 TMDS_P DETECT_N_I 0.04213f
C864 TMDS_P TMDS_N 59.0973f
C865 MAIN_P MAIN_TAIL_7 7.64275f
C866 MAIN_BIAS SUM_N_D_6 0.63786f
C867 DETECT_P_I POST_TAIL_3 0.07832f
C868 MAIN_TAIL_6 SUM_P_D_2 0.12054f
C869 MAIN_TAIL_3 DETECT_N_I 0.09246f
C870 a_45878_133785# a_45878_133225# 0.0346f
C871 POST_P SUM_N_D_0 0.31669f
C872 TMDS_N TMDS_TAIL_4 1.8257f
C873 POST_N SUM_N_D_6 6.46919f
C874 SUM_P_D_6 DETECT_N_I 0.03089f
C875 TERM_P_R SUM_N_D_6 0.91459f
C876 ESD_RAIL a_35813_117064# 4.89902f
C877 TMDS_BIAS SUM_P_D_2 0.09854f
C878 PAD_N MAIN_P 0
C879 TMDS_N SUM_P_D_6 0.11591f
C880 DETECT_BLEED_5 DETECT_N_I 0.0931f
C881 TMDS_N DETECT_BLEED_5 0.06744f
C882 DETECT_ENABLE TMDS_P 0.00693f
C883 SUM_N_D_2 DETECT_N_I 0.03089f
C884 TMDS_N SUM_N_D_2 0.60186f
C885 SUM_P_D_4 POST_TAIL_7 0.08748f
C886 MAIN_N MAIN_TAIL_1 8.98714f
C887 SUM_P_D_5 SUM_N_D_7 0.48462f
C888 POST_TAIL_6 SUM_P_D_3 0.1179f
C889 POST_P MAIN_TAIL_7 0
C890 MAIN_TAIL_2 SUM_P_D_4 0.08656f
C891 POST_BIAS SUM_N_D_4 0.65571f
C892 TERM_BLEED_4 TERM_BLEED_2 0.00326f
C893 TMDS_P SUM_N_D_0 0.04279f
C894 TERM_ENABLE_B TERM_BLEED_1 0
C895 TMDS_TAIL_3 TMDS_TAIL_5 0.00179f
C896 SUM_N_D_4 DETECT_ENABLE_LOCAL 0.04808f
C897 DETECT_ENABLE DETECT_BLEED_5 0.32681f
C898 SUM_N_D_6 DETECT_N_I 0.12335f
C899 MAIN_TAIL_3 SUM_N_D_0 0.1483f
C900 TMDS_N SUM_N_D_6 0.97776f
C901 MAIN_TAIL_4 SUM_P_D_0 0.09024f
C902 CASCODE SUM_P_D_2 3.57788f
C903 POST_N POST_TAIL_6 7.13064f
C904 SUM_N_D_7 SUM_N_D_5 0.07076f
C905 SUM_N_D_0 SUM_P_D_6 0.05692f
C906 TERM_P_R POST_TAIL_6 1.15234f
C907 POST_BIAS TMDS_TAIL_2 0.08866f
C908 MAIN_P TERM_BLEED_1 0.04844f
C909 SUM_N_D_0 SUM_N_D_2 0.10929f
C910 CASCODE POST_TAIL_4 0.01263f
C911 TERM_VCM TERM_BLEED_6 0.01279f
C912 TMDS_TAIL_2 DETECT_ENABLE_LOCAL 0.08279f
C913 MAIN_P SUM_N_D_7 0.23558f
C914 MAIN_N SUM_N_D_4 0.35963f
C915 SUM_N_D_0 SUM_N_D_6 0.11231f
C916 MAIN_TAIL_7 SUM_P_D_6 0.11808f
C917 VDD TERM_BLEED_6 0.00542f
C918 DETECT_BLEED_4 DETECT_BLEED_0 0.12219f
C919 POST_TAIL_2 POST_BIAS 20.1278f
C920 SUM_P_D_4 POST_TAIL_3 0.09491f
C921 MAIN_TAIL_5 SUM_P_D_2 0.11671f
C922 MAIN_TAIL_7 SUM_N_D_2 0.12351f
C923 POST_P TERM_BLEED_1 0.04828f
C924 TMDS_TAIL_7 DETECT_P_I 0.07581f
C925 VDD TERM_ENABLE_B 2.30445f
C926 POST_TAIL_2 DETECT_ENABLE_LOCAL 0.08279f
C927 TERM_VCM MAIN_P 0.11229f
C928 MAIN_TAIL_1 SUM_P_D_3 0.08096f
C929 PAD_N SUM_P_D_6 1.09952f
C930 TMDS_TAIL_0 SUM_P_D_1 0.102f
C931 TERM_BLEED_5 TERM_BLEED_4 0.51151f
C932 PAD_N SUM_N_D_2 2.83094f
C933 MAIN_N TMDS_TAIL_2 0.03631f
C934 POST_P SUM_N_D_7 0.24907f
C935 MAIN_BIAS MAIN_TAIL_1 11.9506f
C936 MAIN_TAIL_7 SUM_N_D_6 0.12326f
C937 a_33684_148611# a_33684_160275# 1.22075p
C938 TERM_N_R SUM_P_D_7 0.64941f
C939 POST_TAIL_1 DETECT_P_I 0.07832f
C940 SUM_P_D_4 DETECT_P_I 0.10679f
C941 SUM_N_D_0 POST_TAIL_6 1.58942f
C942 SUM_N_D_3 TERM_N_R 0.00741f
C943 TERM_P_R MAIN_TAIL_1 0.55002f
C944 TMDS_P TERM_BLEED_1 0.04811f
C945 PAD_N SUM_N_D_6 1.76067f
C946 SUM_P_D_0 SUM_P_D_1 98.7911f
C947 TERM_VCM POST_P 0.25482f
C948 POST_TAIL_2 MAIN_N 0.03631f
C949 PAD_P SUM_N_D_4 1.96735f
C950 TMDS_TAIL_6 TERM_P_R 0.99706f
C951 CASCODE POST_TAIL_5 0.01263f
C952 POST_BIAS SUM_P_D_2 0.58269f
C953 TMDS_P SUM_N_D_7 0.15593f
C954 MAIN_TAIL_1 DETECT_N_I 0.09298f
C955 MAIN_TAIL_3 SUM_N_D_7 0.08807f
C956 POST_P VDD 0.18742f
C957 SUM_P_D_2 DETECT_ENABLE_LOCAL 0.04808f
C958 SUM_N_D_4 SUM_P_D_3 0.09876f
C959 SUM_N_D_7 TMDS_TAIL_4 0.07263f
C960 MAIN_BIAS SUM_N_D_4 0.67896f
C961 POST_BIAS POST_TAIL_4 23.2636f
C962 SUM_P_D_6 SUM_N_D_7 0.28156f
C963 TERM_VCM TMDS_P 0.28334f
C964 SUM_N_D_2 SUM_N_D_7 0.16431f
C965 TMDS_N TMDS_TAIL_6 0.97421f
C966 POST_N SUM_N_D_4 1.38254f
C967 DETECT_ENABLE_LOCAL POST_TAIL_4 0.10084f
C968 SUM_N_D_1 POST_TAIL_7 0.09656f
C969 a_45878_133225# a_45878_132665# 0.0346f
C970 SUM_N_D_4 TERM_P_R 0.39341f
C971 TMDS_TAIL_2 SUM_P_D_3 0.17343f
C972 MAIN_TAIL_4 TERM_N_R 1.03641f
C973 MAIN_TAIL_2 SUM_N_D_1 0.15814f
C974 TERM_N_R TMDS_TAIL_5 0.52483f
C975 TMDS_P VDD 0.42824f
C976 SUM_N_D_6 SUM_N_D_7 99.39851f
C977 SUM_N_D_0 MAIN_TAIL_1 0.18921f
C978 MAIN_BIAS TMDS_TAIL_2 0.03684f
C979 MAIN_N SUM_P_D_2 0.13247f
C980 ESD_RAIL a_34245_90628# 0.24367p
C981 POST_N TMDS_TAIL_2 0.06298f
C982 SUM_N_D_4 DETECT_N_I 0.03089f
C983 TERM_P_R TMDS_TAIL_2 1.24011f
C984 VDD DETECT_BLEED_5 0.38732f
C985 TMDS_N SUM_N_D_4 0.62938f
C986 POST_TAIL_1 SUM_P_D_4 0.08656f
C987 POST_TAIL_2 SUM_P_D_3 0.08868f
C988 MAIN_N POST_TAIL_4 0.02404f
C989 DETECT_BLEED_0 DETECT_BLEED_3 0.11971f
C990 POST_TAIL_2 MAIN_BIAS 0.03684f
C991 TMDS_TAIL_0 SUM_P_D_0 1.93859f
C992 TMDS_TAIL_2 DETECT_N_I 0.09246f
C993 POST_TAIL_6 SUM_N_D_7 0.11863f
C994 POST_TAIL_2 POST_N 2.18047f
C995 TMDS_N TMDS_TAIL_2 3.36739f
C996 POST_TAIL_2 TERM_P_R 0.76819f
C997 TERM_P_R TERM_BLEED_0 0.77399f
C998 POST_BIAS POST_TAIL_5 14.4029f
C999 SUM_N_D_1 POST_TAIL_3 0.09066f
C1000 SUM_N_D_0 SUM_N_D_4 0.2453f
C1001 PAD_P SUM_P_D_2 2.16967f
C1002 POST_TAIL_5 DETECT_ENABLE_LOCAL 0.10084f
C1003 POST_BIAS TERM_BLEED_2 0.07928f
C1004 POST_BIAS DETECT_PBIAS 0.04862f
C1005 TERM_ENABLE TERM_BLEED_0 0.16586f
C1006 DETECT_ENABLE_LOCAL MAIN_TAIL_0 0
C1007 POST_TAIL_2 DETECT_N_I 0.09246f
C1008 SUM_P_D_1 TERM_N_R 0.84667f
C1009 SUM_N_D_1 DETECT_P_I 0.02846f
C1010 SUM_P_D_2 SUM_P_D_3 98.7886f
C1011 TMDS_N TERM_BLEED_0 0.06644f
C1012 SUM_N_D_0 TMDS_TAIL_2 0.00305f
C1013 MAIN_TAIL_7 SUM_N_D_4 0.12193f
C1014 MAIN_BIAS SUM_P_D_2 0.59966f
C1015 DETECT_BLEED_6 TERM_BLEED_2 0
C1016 POST_N SUM_P_D_2 0.21826f
C1017 SUM_P_D_3 POST_TAIL_4 0.11715f
C1018 TMDS_BIAS DETECT_BLEED_0 0.00355f
C1019 SUM_P_D_2 TERM_P_R 0.03472f
C1020 MAIN_N POST_TAIL_5 0.02404f
C1021 MAIN_BIAS POST_TAIL_4 0.02404f
C1022 PAD_N SUM_N_D_4 2.12235f
C1023 MAIN_N DETECT_PBIAS 0.06578f
C1024 MAIN_N MAIN_TAIL_0 10.7195f
C1025 MAIN_TAIL_1 SUM_N_D_7 0.08169f
C1026 POST_N POST_TAIL_4 1.50285f
C1027 MAIN_N TERM_BLEED_2 0.02441f
C1028 POST_TAIL_2 SUM_N_D_0 0.61038f
C1029 POST_TAIL_0 SUM_P_D_7 0.13897f
C1030 POST_TAIL_0 SUM_N_D_3 0.08318f
C1031 TERM_P_R POST_TAIL_4 1.08962f
C1032 MAIN_P DETECT_BLEED_2 0.08856f
C1033 SUM_P_D_2 DETECT_N_I 0.03089f
C1034 TMDS_TAIL_6 SUM_N_D_7 0.0374f
C1035 TMDS_N SUM_P_D_2 0.02964f
C1036 CASCODE DETECT_BLEED_0 0.79203f
C1037 MAIN_TAIL_6 SUM_P_D_7 0.19092f
C1038 POST_TAIL_7 SUM_P_D_5 0.08752f
C1039 MAIN_TAIL_6 SUM_N_D_3 0.12193f
C1040 MAIN_TAIL_2 SUM_P_D_5 0.08698f
C1041 DETECT_N_I POST_TAIL_4 0.04845f
C1042 TMDS_BIAS SUM_P_D_7 0.39711f
C1043 TMDS_BIAS SUM_N_D_3 0.08749f
C1044 TERM_ENABLE_LOCAL TERM_BLEED_6 0.36008f
C1045 POST_P DETECT_BLEED_2 0.09064f
C1046 a_33005_131825# a_33005_131545# 0.03725f
C1047 POST_TAIL_7 SUM_N_D_5 0.09129f
C1048 SUM_N_D_4 SUM_N_D_7 0.12493f
C1049 POST_TAIL_1 SUM_N_D_1 2.48513f
C1050 SUM_P_D_4 SUM_N_D_1 0.17165f
C1051 PAD_P MAIN_TAIL_0 0.00548f
C1052 SUM_N_D_0 SUM_P_D_2 0.20257f
C1053 TERM_ENABLE_B TERM_ENABLE_LOCAL 3.20225f
C1054 MAIN_TAIL_2 SUM_N_D_5 0.08658f
C1055 POST_TAIL_5 SUM_P_D_3 0.12054f
C1056 DETECT_BLEED_0 DETECT_BLEED_1 2.38285f
C1057 TMDS_TAIL_0 TERM_N_R 0.98454f
C1058 CASCODE SUM_P_D_7 1.24211f
C1059 MAIN_BIAS POST_TAIL_5 0.02404f
C1060 SUM_P_D_3 MAIN_TAIL_0 0.1179f
C1061 CASCODE SUM_N_D_3 6.57289f
C1062 SUM_N_D_0 POST_TAIL_4 0.89963f
C1063 MAIN_P POST_TAIL_7 0.04932f
C1064 MAIN_P TERM_ENABLE_LOCAL 0.11272f
C1065 MAIN_BIAS DETECT_PBIAS 2.12341f
C1066 POST_N POST_TAIL_5 3.01715f
C1067 TMDS_TAIL_3 TERM_N_R 0.2627f
C1068 TMDS_TAIL_2 SUM_N_D_7 0.11255f
C1069 MAIN_P MAIN_TAIL_2 5.42545f
C1070 MAIN_BIAS MAIN_TAIL_0 20.1582f
C1071 MAIN_BIAS TERM_BLEED_2 0.02451f
C1072 MAIN_TAIL_7 SUM_P_D_2 0.1179f
C1073 TERM_P_R POST_TAIL_5 1.1553f
C1074 SUM_P_D_5 POST_TAIL_3 0.09024f
C1075 SUM_P_D_0 TERM_N_R 0.64941f
C1076 TERM_BLEED_2 TERM_BLEED_3 3.51974f
C1077 POST_N DETECT_PBIAS 0.0353f
C1078 POST_N TERM_BLEED_2 0.0525f
C1079 TERM_P_R MAIN_TAIL_0 1.15659f
C1080 TERM_BLEED_1 TERM_BLEED_0 5.0148f
C1081 DETECT_BLEED_5 DETECT_BLEED_2 0.10559f
C1082 TERM_P_R TERM_BLEED_2 0.00257f
C1083 PAD_N SUM_P_D_2 1.77672f
C1084 TMDS_BIAS TMDS_TAIL_5 3.44569f
C1085 POST_P POST_TAIL_7 3.73762f
C1086 POST_TAIL_2 SUM_N_D_7 0.08807f
C1087 POST_P TERM_ENABLE_LOCAL 0.21419f
C1088 POST_TAIL_5 DETECT_N_I 0.04845f
C1089 SUM_P_D_5 DETECT_P_I 0.18511f
C1090 SUM_P_D_7 DETECT_BLEED_1 0
C1091 MAIN_TAIL_5 SUM_P_D_7 0.18785f
C1092 SUM_N_D_5 POST_TAIL_3 0.09024f
C1093 TERM_ENABLE TERM_BLEED_2 0.08101f
C1094 MAIN_TAIL_5 SUM_N_D_3 0.11671f
C1095 DETECT_PBIAS DETECT_N_I 4.61189f
C1096 DETECT_N_I MAIN_TAIL_0 0
C1097 DETECT_ENABLE_LOCAL DETECT_BLEED_0 0.50637f
C1098 TERM_BLEED_2 DETECT_N_I 0.06991f
C1099 CASCODE TMDS_TAIL_5 0.01263f
C1100 MAIN_P POST_TAIL_3 0.04932f
C1101 DETECT_BLEED_6 DETECT_BLEED_0 0.00763f
C1102 DETECT_P_I SUM_N_D_5 0.10679f
C1103 TMDS_P POST_TAIL_7 0
C1104 TMDS_P TERM_ENABLE_LOCAL 0.284f
C1105 DETECT_ENABLE DETECT_PBIAS 0.79432f
C1106 DETECT_ENABLE TERM_BLEED_2 0.03876f
C1107 POST_TAIL_0 SUM_P_D_1 0.08096f
C1108 SUM_N_D_0 POST_TAIL_5 1.23043f
C1109 VDD TERM_BLEED_0 0.80208f
C1110 TERM_BLEED_5 TERM_BLEED_3 0.06546f
C1111 MAIN_TAIL_3 MAIN_TAIL_2 3.11815f
C1112 SUM_P_D_6 POST_TAIL_7 0.08756f
C1113 SUM_N_D_0 MAIN_TAIL_0 4.49059f
C1114 POST_BIAS SUM_P_D_7 1.03978f
C1115 SUM_P_D_2 SUM_N_D_7 0.85965f
C1116 MAIN_N DETECT_BLEED_0 0.02915f
C1117 MAIN_P DETECT_P_I 0.07166f
C1118 POST_TAIL_7 SUM_N_D_2 0.09405f
C1119 TERM_BLEED_5 TERM_P_R 0.28727f
C1120 MAIN_TAIL_2 SUM_P_D_6 0.08739f
C1121 SUM_P_D_4 TMDS_TAIL_1 0
C1122 POST_BIAS SUM_N_D_3 0.69808f
C1123 POST_P POST_TAIL_3 2.27034f
C1124 MAIN_TAIL_6 SUM_P_D_1 0.12054f
C1125 DETECT_ENABLE_LOCAL SUM_P_D_7 0.125f
C1126 MAIN_TAIL_2 SUM_N_D_2 2.44032f
C1127 SUM_N_D_3 DETECT_ENABLE_LOCAL 0.11405f
C1128 MAIN_TAIL_5 MAIN_TAIL_4 1.39669f
C1129 SUM_N_D_7 POST_TAIL_4 0.11671f
C1130 DETECT_ENABLE_B DETECT_BLEED_0 0.00167f
C1131 TERM_ENABLE TERM_BLEED_5 0.27874f
C1132 TMDS_BIAS SUM_P_D_1 0.11095f
C1133 a_36789_117064# a_33005_131545# 0.02879f
C1134 SUM_N_D_6 POST_TAIL_7 0.09094f
C1135 MAIN_TAIL_2 SUM_N_D_6 0.0863f
C1136 POST_P DETECT_P_I 0.03053f
C1137 a_33005_132945# a_33005_132385# 0.0346f
C1138 POST_TAIL_1 SUM_P_D_5 0.08698f
C1139 SUM_P_D_4 SUM_P_D_5 98.0735f
C1140 TMDS_TAIL_7 SUM_N_D_5 0.00305f
C1141 m2_34279_124800# a_33005_132945# 0
C1142 MAIN_N SUM_P_D_7 0.21797f
C1143 CASCODE SUM_P_D_1 6.06489f
C1144 MAIN_N SUM_N_D_3 1.61442f
C1145 a_35813_117064# a_36789_117064# 2.94235f
C1146 SUM_P_D_6 POST_TAIL_3 0.09024f
C1147 POST_TAIL_6 POST_TAIL_7 0.0263f
C1148 SUM_N_D_2 POST_TAIL_3 0.19715f
C1149 TMDS_P DETECT_P_I 0.03053f
C1150 POST_TAIL_1 SUM_N_D_5 0.08658f
C1151 SUM_P_D_4 SUM_N_D_5 0.12103f
C1152 POST_BIAS TMDS_TAIL_5 0.07486f
C1153 SUM_P_D_7 DETECT_ENABLE_B 0.1142f
C1154 MAIN_P TMDS_TAIL_7 0.04932f
C1155 MAIN_TAIL_3 DETECT_P_I 0.07884f
C1156 MAIN_TAIL_4 DETECT_ENABLE_LOCAL 0.08279f
C1157 TMDS_TAIL_5 DETECT_ENABLE_LOCAL 0.10084f
C1158 MAIN_BIAS DETECT_BLEED_0 0.02938f
C1159 m2_34279_124800# a_33005_132385# 0
C1160 TERM_N_R DETECT_BLEED_4 0.80141f
C1161 SUM_P_D_6 DETECT_P_I 0.02846f
C1162 SUM_N_D_6 POST_TAIL_3 0.09024f
C1163 DETECT_BLEED_5 DETECT_P_I 0.07445f
C1164 MAIN_P POST_TAIL_1 0.04932f
C1165 MAIN_P SUM_P_D_4 0.40699f
C1166 TERM_BLEED_1 TERM_BLEED_2 5.16434f
C1167 SUM_N_D_2 DETECT_P_I 0.02846f
C1168 SUM_N_D_7 POST_TAIL_5 0.12126f
C1169 MAIN_TAIL_5 SUM_P_D_1 0.11671f
C1170 POST_P TMDS_TAIL_7 0.11443f
C1171 SUM_N_D_7 MAIN_TAIL_0 0.11863f
C1172 PAD_P SUM_P_D_7 2.51323f
C1173 PAD_P SUM_N_D_3 3.02784f
C1174 SUM_N_D_6 DETECT_P_I 0.10679f
C1175 POST_TAIL_0 SUM_P_D_0 1.85742f
C1176 MAIN_N MAIN_TAIL_4 2.82444f
C1177 MAIN_N TMDS_TAIL_5 0.02404f
C1178 DETECT_N_I DETECT_BLEED_0 0.07169f
C1179 TMDS_BIAS TMDS_TAIL_0 11.6619f
C1180 SUM_P_D_3 SUM_P_D_7 0.09253f
C1181 POST_P SUM_P_D_4 3.10283f
C1182 POST_P POST_TAIL_1 3.83855f
C1183 SUM_N_D_3 SUM_P_D_3 0.13986f
C1184 TERM_VCM DETECT_PBIAS 0.05209f
C1185 MAIN_BIAS SUM_P_D_7 1.68279f
C1186 MAIN_BIAS SUM_N_D_3 0.65031f
C1187 MAIN_TAIL_6 SUM_P_D_0 0.12054f
C1188 TMDS_BIAS TMDS_TAIL_3 2.65883f
C1189 TMDS_P TMDS_TAIL_7 6.79426f
C1190 MAIN_TAIL_2 MAIN_TAIL_1 4.0354f
C1191 POST_N SUM_P_D_7 0.24326f
C1192 POST_N SUM_N_D_3 0.40172f
C1193 ESD_RAIL a_45878_133785# 0.53942f
C1194 DETECT_ENABLE DETECT_BLEED_0 0.17833f
C1195 TERM_P_R SUM_P_D_7 0.76182f
C1196 POST_BIAS SUM_P_D_1 0.55963f
C1197 VDD DETECT_PBIAS 3.45521f
C1198 TMDS_BIAS SUM_P_D_0 0.02535f
C1199 TERM_P_R SUM_N_D_3 0.03472f
C1200 SUM_N_D_1 TMDS_TAIL_1 1.87559f
C1201 SUM_P_D_6 TMDS_TAIL_7 0.00305f
C1202 SUM_P_D_1 DETECT_ENABLE_LOCAL 0.04808f
C1203 TMDS_P SUM_P_D_4 0.62985f
C1204 TERM_BLEED_5 TERM_BLEED_1 0
C1205 MAIN_TAIL_3 SUM_P_D_4 0.08899f
C1206 SUM_P_D_4 TMDS_TAIL_4 1.97812f
C1207 CASCODE TMDS_TAIL_3 0.01263f
C1208 SUM_P_D_7 DETECT_N_I 0.11985f
C1209 TMDS_N SUM_P_D_7 0.21421f
C1210 SUM_N_D_3 DETECT_N_I 0.12335f
C1211 POST_TAIL_1 SUM_P_D_6 0.08739f
C1212 SUM_P_D_4 SUM_P_D_6 0.03862f
C1213 CASCODE SUM_P_D_0 2.44861f
C1214 TMDS_N SUM_N_D_3 3.88027f
C1215 SUM_N_D_6 TMDS_TAIL_7 0.00539f
C1216 POST_TAIL_1 SUM_N_D_2 0.08857f
C1217 SUM_P_D_4 SUM_N_D_2 0.15955f
C1218 SUM_N_D_4 POST_TAIL_7 0.09182f
C1219 MAIN_TAIL_4 SUM_P_D_3 0.13376f
C1220 SUM_N_D_1 SUM_P_D_5 0.20637f
C1221 MAIN_TAIL_2 SUM_N_D_4 0.08699f
C1222 TERM_BLEED_4 TERM_N_R 0
C1223 MAIN_BIAS MAIN_TAIL_4 29.9265f
C1224 DETECT_ENABLE SUM_P_D_7 0.08005f
C1225 MAIN_N SUM_P_D_1 0.12629f
C1226 MAIN_BIAS TMDS_TAIL_5 0.02404f
C1227 ESD_RAIL a_33005_131825# 0.53823f
C1228 POST_TAIL_1 SUM_N_D_6 0.0863f
C1229 SUM_P_D_4 SUM_N_D_6 0.15884f
C1230 POST_N TMDS_TAIL_5 0.04808f
C1231 MAIN_TAIL_4 TERM_P_R 1.09162f
C1232 SUM_N_D_0 SUM_P_D_7 0.12799f
C1233 TERM_N_R DETECT_BLEED_3 0.39463f
C1234 TERM_P_R TMDS_TAIL_5 0.52483f
C1235 SUM_N_D_1 SUM_N_D_5 0.20513f
C1236 SUM_N_D_0 SUM_N_D_3 0.19012f
C1237 MAIN_TAIL_1 DETECT_P_I 0.07933f
C1238 MAIN_TAIL_5 SUM_P_D_0 0.11671f
C1239 DETECT_BLEED_4 DETECT_BLEED_3 6.95031f
C1240 a_36789_117064# a_34245_90628# 10.1844f
C1241 MAIN_P SUM_N_D_1 0.23846f
C1242 MAIN_TAIL_4 DETECT_N_I 0.09246f
C1243 TMDS_TAIL_5 DETECT_N_I 0.04845f
C1244 MAIN_TAIL_7 SUM_P_D_7 1.95032f
C1245 TMDS_N TMDS_TAIL_5 6.55859f
C1246 SUM_P_D_4 POST_TAIL_6 0.11799f
C1247 POST_TAIL_0 TERM_N_R 0.7096f
C1248 MAIN_TAIL_7 SUM_N_D_3 0.12255f
C1249 POST_BIAS TMDS_TAIL_0 0.11601f
C1250 TERM_ENABLE_LOCAL TERM_BLEED_0 2.74173f
C1251 SUM_N_D_4 POST_TAIL_3 0.09024f
C1252 PAD_P SUM_P_D_1 3.60616f
C1253 TMDS_TAIL_0 DETECT_ENABLE_LOCAL 0.08279f
C1254 PAD_N SUM_P_D_7 0.96404f
C1255 PAD_N SUM_N_D_3 3.18913f
C1256 POST_BIAS TMDS_TAIL_3 0.03743f
C1257 SUM_P_D_1 SUM_P_D_3 0.19147f
C1258 MAIN_TAIL_6 TERM_N_R 1.11782f
C1259 TMDS_TAIL_3 DETECT_ENABLE_LOCAL 0.10084f
C1260 POST_P SUM_N_D_1 0.23846f
C1261 POST_BIAS SUM_P_D_0 0.80805f
C1262 SUM_N_D_4 DETECT_P_I 0.02846f
C1263 MAIN_BIAS SUM_P_D_1 0.77049f
C1264 MAIN_TAIL_4 SUM_N_D_0 0.15072f
C1265 TMDS_BIAS TERM_N_R 2.47422f
C1266 SUM_P_D_0 DETECT_ENABLE_LOCAL 0.04808f
C1267 POST_N SUM_P_D_1 0.13049f
C1268 TERM_P_R SUM_P_D_1 0.89676f
C1269 SUM_P_D_2 POST_TAIL_7 0.08739f
C1270 MAIN_N TMDS_TAIL_0 0.03631f
C1271 TMDS_TAIL_1 SUM_P_D_5 0
C1272 TMDS_TAIL_2 DETECT_P_I 0.07832f
C1273 TMDS_BIAS DETECT_BLEED_4 0.04427f
C1274 MAIN_TAIL_2 SUM_P_D_2 1.81473f
C1275 TMDS_P SUM_N_D_1 0.1767f
C1276 POST_TAIL_2 POST_TAIL_3 0.9779f
C1277 TMDS_TAIL_6 TMDS_TAIL_7 0.01431f
C1278 SUM_P_D_4 MAIN_TAIL_1 0.08105f
C1279 MAIN_N TMDS_TAIL_3 0.02404f
C1280 MAIN_TAIL_3 SUM_N_D_1 0.08792f
C1281 ESD_RAIL a_45878_132665# 0.53916f
C1282 SUM_P_D_1 DETECT_N_I 0.03089f
C1283 TMDS_N SUM_P_D_1 0.07218f
C1284 SUM_N_D_7 SUM_P_D_7 0.5577f
C1285 MAIN_N SUM_P_D_0 0.12549f
C1286 SUM_N_D_1 SUM_P_D_6 0.09966f
C1287 SUM_N_D_3 SUM_N_D_7 0.09165f
C1288 POST_TAIL_2 DETECT_P_I 0.07832f
C1289 SUM_N_D_1 SUM_N_D_2 99.3788f
C1290 CASCODE DETECT_BLEED_4 0.08101f
C1291 ESD_RAIL a_36789_117064# 13.9519f
C1292 SUM_N_D_1 SUM_N_D_6 0.14364f
C1293 MAIN_TAIL_5 TERM_N_R 1.04845f
C1294 SUM_N_D_0 SUM_P_D_1 0.10504f
C1295 SUM_P_D_2 POST_TAIL_3 0.14407f
C1296 SUM_P_D_5 SUM_N_D_5 0.27406f
C1297 POST_TAIL_1 SUM_N_D_4 0.08699f
C1298 SUM_P_D_4 SUM_N_D_4 0.24443f
C1299 TMDS_TAIL_0 SUM_P_D_3 0.08296f
C1300 MAIN_BIAS TMDS_TAIL_0 0.03684f
C1301 POST_TAIL_3 POST_TAIL_4 0.08699f
C1302 DETECT_BLEED_4 DETECT_BLEED_1 0.12236f
C1303 PAD_P SUM_P_D_0 2.80054f
C1304 MAIN_TAIL_4 SUM_N_D_7 0.09024f
C1305 SUM_P_D_2 DETECT_P_I 0.02846f
C1306 TMDS_TAIL_3 SUM_P_D_3 1.83413f
C1307 POST_N TMDS_TAIL_0 0.14505f
C1308 MAIN_P SUM_P_D_5 0.86696f
C1309 SUM_N_D_7 TMDS_TAIL_5 0.07395f
C1310 MAIN_TAIL_7 SUM_P_D_1 0.1179f
C1311 SUM_N_D_1 POST_TAIL_6 0.12554f
C1312 TMDS_TAIL_0 TERM_P_R 0.98454f
C1313 SUM_P_D_4 TMDS_TAIL_2 0.08473f
C1314 SUM_P_D_0 SUM_P_D_3 0.16736f
C1315 MAIN_BIAS TMDS_TAIL_3 0.02404f
C1316 DETECT_P_I POST_TAIL_4 0.03087f
C1317 POST_N TMDS_TAIL_3 0.02404f
C1318 MAIN_BIAS SUM_P_D_0 1.4305f
C1319 DETECT_PBIAS TERM_ENABLE_LOCAL 0.01235f
C1320 PAD_N SUM_P_D_1 2.72513f
C1321 TERM_ENABLE_LOCAL TERM_BLEED_2 0
C1322 TMDS_TAIL_3 TERM_P_R 0.49987f
C1323 POST_BIAS TERM_N_R 5.19834f
C1324 MAIN_P SUM_N_D_5 0.21527f
C1325 POST_N SUM_P_D_0 0.15033f
C1326 TERM_N_R DETECT_ENABLE_LOCAL 0.79639f
C1327 TMDS_TAIL_0 DETECT_N_I 0.09246f
C1328 TMDS_P TMDS_TAIL_1 1.61906f
C1329 TERM_P_R SUM_P_D_0 0.74403f
C1330 POST_P SUM_P_D_5 5.98984f
C1331 POST_TAIL_2 POST_TAIL_1 1.8883f
C1332 POST_TAIL_2 SUM_P_D_4 0.08899f
C1333 TMDS_N TMDS_TAIL_0 4.79616f
C1334 DETECT_BLEED_6 TERM_N_R 0.45286f
C1335 POST_BIAS DETECT_BLEED_4 0.08856f
C1336 TMDS_TAIL_3 DETECT_N_I 0.04845f
C1337 TMDS_TAIL_1 SUM_P_D_6 0
C1338 TMDS_N TMDS_TAIL_3 8.10468f
C1339 DETECT_ENABLE_LOCAL DETECT_BLEED_4 0.12659f
C1340 SUM_P_D_0 DETECT_N_I 0.03089f
C1341 TMDS_N SUM_P_D_0 0.05063f
C1342 POST_P SUM_N_D_5 0.32101f
C1343 POST_P TERM_ENABLE_B 0.04813f
C1344 MAIN_N TERM_N_R 1.15923f
C1345 ESD_RAIL a_45878_131545# 0.56772f
C1346 TMDS_P SUM_P_D_5 4.68502f
C1347 DETECT_BLEED_6 DETECT_BLEED_4 0.00855f
C1348 SUM_N_D_0 TMDS_TAIL_0 1.93932f
C1349 SUM_N_D_1 MAIN_TAIL_1 3.36912f
C1350 CASCODE DETECT_BLEED_3 0.10387f
C1351 MAIN_TAIL_3 SUM_P_D_5 0.08941f
C1352 SUM_P_D_5 TMDS_TAIL_4 0.05738f
C1353 SUM_P_D_1 SUM_N_D_7 1.00452f
C1354 TMDS_P TERM_BLEED_6 0.06074f
C1355 MAIN_P POST_P 0.03757f
C1356 SUM_P_D_6 SUM_P_D_5 98.70889f
C1357 TERM_BLEED_5 TERM_ENABLE_LOCAL 0.06295f
C1358 TERM_N_R DETECT_ENABLE_B 1.11273f
C1359 POST_TAIL_1 SUM_P_D_2 0.08603f
C1360 SUM_P_D_4 SUM_P_D_2 0.10112f
C1361 SUM_N_D_2 SUM_P_D_5 0.19437f
C1362 POST_TAIL_5 DETECT_P_I 0.03087f
C1363 MAIN_N DETECT_BLEED_4 0.06178f
C1364 TMDS_P SUM_N_D_5 0.08666f
C1365 SUM_N_D_0 SUM_P_D_0 0.44065f
C1366 MAIN_TAIL_3 SUM_N_D_5 0.08781f
C1367 DETECT_PBIAS DETECT_P_I 1.85788f
C1368 TMDS_TAIL_4 SUM_N_D_5 0.05382f
C1369 DETECT_P_I MAIN_TAIL_0 0.02768f
C1370 TERM_BLEED_2 DETECT_P_I 0.03138f
C1371 SUM_P_D_4 POST_TAIL_4 2.33289f
C1372 m2_34279_124800# a_33005_134065# 0
C1373 SUM_N_D_6 SUM_P_D_5 0.18444f
C1374 DETECT_BLEED_2 DETECT_BLEED_0 0.12112f
C1375 SUM_N_D_2 SUM_N_D_5 0.19044f
C1376 MAIN_P TMDS_P 0.03757f
C1377 DETECT_BLEED_3 DETECT_BLEED_1 0.12036f
C1378 MAIN_TAIL_3 MAIN_P 3.35524f
C1379 PAD_P TERM_N_R 0.03209f
C1380 SUM_N_D_1 SUM_N_D_4 0.19909f
C1381 MAIN_TAIL_7 SUM_P_D_0 0.1179f
C1382 CASCODE MAIN_TAIL_6 0.01263f
C1383 MAIN_P SUM_P_D_6 5.85764f
C1384 SUM_N_D_6 SUM_N_D_5 0.10003p
C1385 MAIN_P DETECT_BLEED_5 0.08856f
C1386 MAIN_P SUM_N_D_2 0.23771f
C1387 TERM_N_R SUM_P_D_3 0.6491f
C1388 PAD_N SUM_P_D_0 1.61819f
C1389 MAIN_BIAS TERM_N_R 5.55839f
C1390 POST_TAIL_6 SUM_P_D_5 0.11804f
C1391 POST_P TMDS_P 0.12581f
C1392 SUM_N_D_1 TMDS_TAIL_2 0.59137f
C1393 POST_BIAS TERM_BLEED_4 0
C1394 TERM_N_R TERM_BLEED_3 0
C1395 POST_N TERM_N_R 1.17645f
C1396 MAIN_P SUM_N_D_6 0.29808f
C1397 POST_P TMDS_TAIL_4 0.053f
C1398 TERM_P_R TERM_N_R 70.0794f
C1399 POST_P SUM_P_D_6 4.11661f
C1400 POST_P DETECT_BLEED_5 0.08856f
C1401 POST_BIAS DETECT_BLEED_3 0.08856f
C1402 MAIN_BIAS DETECT_BLEED_4 0.06178f
C1403 POST_P SUM_N_D_2 0.15982f
C1404 MAIN_TAIL_5 MAIN_TAIL_6 0.41143f
C1405 POST_TAIL_6 SUM_N_D_5 0.12327f
C1406 DETECT_ENABLE_LOCAL DETECT_BLEED_3 0.12346f
C1407 TMDS_TAIL_0 SUM_N_D_7 0.16512f
C1408 POST_N DETECT_BLEED_4 0.06178f
C1409 POST_TAIL_2 SUM_N_D_1 0.16236f
C1410 TERM_ENABLE TERM_N_R 0.26141f
C1411 SUM_P_D_4 POST_TAIL_5 0.12124f
C1412 TERM_P_R DETECT_BLEED_4 0.9086f
C1413 TMDS_BIAS DETECT_BLEED_1 0
C1414 TERM_N_R DETECT_N_I 0.23779f
C1415 SUM_P_D_4 MAIN_TAIL_0 0.11799f
C1416 TMDS_N TERM_N_R 1.90553f
C1417 POST_P SUM_N_D_6 0.23565f
C1418 TMDS_P TMDS_TAIL_4 3.77228f
C1419 DETECT_BLEED_6 DETECT_BLEED_3 0.0078f
C1420 TMDS_TAIL_3 SUM_N_D_7 0.0359f
C1421 a_33005_133505# a_33005_132945# 0.0346f
C1422 TMDS_P SUM_P_D_6 0.66197f
C1423 TMDS_P DETECT_BLEED_5 0.10851f
C1424 SUM_P_D_0 SUM_N_D_7 80.7051f
C1425 POST_BIAS POST_TAIL_0 9.02802f
C1426 MAIN_TAIL_3 SUM_P_D_6 0.08982f
C1427 TMDS_P SUM_N_D_2 0.07372f
C1428 DETECT_N_I DETECT_BLEED_4 0.0931f
C1429 SUM_P_D_6 TMDS_TAIL_4 0.05302f
C1430 MAIN_TAIL_3 SUM_N_D_2 0.16213f
C1431 TMDS_N DETECT_BLEED_4 0.03181f
C1432 POST_TAIL_0 DETECT_ENABLE_LOCAL 0.08279f
C1433 DETECT_ENABLE TERM_N_R 0.48455f
C1434 MAIN_TAIL_1 SUM_P_D_5 0.0811f
C1435 CASCODE DETECT_BLEED_1 0.23767f
C1436 MAIN_TAIL_5 CASCODE 0.01263f
C1437 MAIN_N DETECT_BLEED_3 0.06178f
C1438 SUM_P_D_6 SUM_N_D_2 0.08774f
C1439 POST_TAIL_7 SUM_P_D_7 1.92671f
C1440 TMDS_P SUM_N_D_6 0.13045f
C1441 POST_BIAS MAIN_TAIL_6 0
C1442 SUM_N_D_0 TERM_N_R 0.6857f
C1443 POST_TAIL_7 SUM_N_D_3 0.09266f
C1444 MAIN_TAIL_3 SUM_N_D_6 0.08781f
C1445 SUM_N_D_1 SUM_P_D_2 0.17437f
C1446 TMDS_TAIL_6 SUM_P_D_5 0
C1447 POST_P POST_TAIL_6 5.52645f
C1448 MAIN_TAIL_2 SUM_P_D_7 0.14535f
C1449 MAIN_TAIL_6 DETECT_ENABLE_LOCAL 0.10084f
C1450 DETECT_ENABLE DETECT_BLEED_4 0.24176f
C1451 SUM_N_D_6 TMDS_TAIL_4 0.04861f
C1452 POST_BIAS TMDS_BIAS 0.20932f
C1453 MAIN_TAIL_2 SUM_N_D_3 0.0876f
C1454 m2_34279_124800# a_33005_133505# 0
C1455 SUM_P_D_6 SUM_N_D_6 0.67747f
C1456 MAIN_TAIL_1 SUM_N_D_5 0.08216f
C1457 TMDS_BIAS DETECT_ENABLE_LOCAL 0.34933f
C1458 SUM_N_D_1 POST_TAIL_4 0.11711f
C1459 SUM_N_D_6 SUM_N_D_2 0.12907f
C1460 MAIN_N POST_TAIL_0 0.14829f
C1461 MAIN_TAIL_7 TERM_N_R 1.06959f
C1462 TMDS_TAIL_6 SUM_N_D_5 0.00655f
C1463 ATB_ESD_RAIL VSS 0.86326f
C1464 PAD_N VSS 0.34885p
C1465 CASCODE VSS 0.12007p
C1466 PAD_P VSS 0.34172p
C1467 MAIN_P VSS 38.6085f
C1468 MAIN_BIAS VSS 0.11563p
C1469 MAIN_N VSS 23.0452f
C1470 POST_N VSS 18.0874f
C1471 POST_P VSS 27.9279f
C1472 POST_BIAS VSS 0.13256p
C1473 DETECT_ENABLE VSS 6.80442f
C1474 TMDS_N VSS 25.1711f
C1475 TMDS_P VSS 31.2273f
C1476 TMDS_BIAS VSS 0.10478p
C1477 TERM_ENABLE VSS 11.0517f
C1478 DETECT_PBIAS VSS 2.3133f
C1479 TERM_VCM VSS 0.11809p
C1480 ESD_RAIL VSS 1841.055664f
C1481 VDD VSS 94.5942f
C1482 m2_34279_124800# VSS 7.46506f $ **FLOATING
C1483 a_34245_90628# VSS 0.24984p
C1484 a_36789_117064# VSS 12.0947f
C1485 a_35813_117064# VSS 5.60447f
C1486 MAIN_TAIL_0 VSS 34.5095f
C1487 MAIN_TAIL_1 VSS 29.4104f
C1488 MAIN_TAIL_2 VSS 29.3365f
C1489 a_33005_131545# VSS 0.10822p
C1490 a_45878_131545# VSS 0.07835f
C1491 a_33005_131825# VSS 0.07377f
C1492 a_45878_132105# VSS 0.07394f
C1493 a_33005_132385# VSS 0.07377f
C1494 a_45878_132665# VSS 0.07394f
C1495 a_33005_132945# VSS 0.07377f
C1496 a_45878_133225# VSS 0.07394f
C1497 a_33005_133505# VSS 0.07377f
C1498 a_45878_133785# VSS 0.07394f
C1499 a_33005_134065# VSS 0.07377f
C1500 MAIN_TAIL_3 VSS 29.5243f
C1501 a_45878_134345# VSS 0.07838f
C1502 MAIN_TAIL_4 VSS 30.3799f
C1503 MAIN_TAIL_5 VSS 32.6152f
C1504 MAIN_TAIL_7 VSS 33.8435f
C1505 MAIN_TAIL_6 VSS 35.4696f
C1506 POST_TAIL_0 VSS 27.0841f
C1507 a_33684_148611# VSS 0.28621p
C1508 POST_TAIL_1 VSS 27.5206f
C1509 POST_TAIL_2 VSS 29.1249f
C1510 POST_TAIL_3 VSS 31.1303f
C1511 a_33684_160275# VSS 1.50941p
C1512 POST_TAIL_4 VSS 34.8492f
C1513 POST_TAIL_6 VSS 30.8428f
C1514 POST_TAIL_5 VSS 34.0492f
C1515 POST_TAIL_7 VSS 29.0761f
C1516 SUM_N_D_1 VSS 29.7929f
C1517 SUM_P_D_1 VSS 29.2744f
C1518 TMDS_TAIL_1 VSS 19.1797f
C1519 SUM_N_D_0 VSS 37.1915f
C1520 SUM_P_D_0 VSS 28.6749f
C1521 TMDS_TAIL_0 VSS 30.7746f
C1522 SUM_P_D_3 VSS 33.8925f
C1523 SUM_N_D_2 VSS 25.7751f
C1524 SUM_P_D_2 VSS 22.0095f
C1525 TMDS_TAIL_2 VSS 31.9084f
C1526 SUM_N_D_4 VSS 24.5905f
C1527 SUM_P_D_4 VSS 25.5136f
C1528 TMDS_TAIL_4 VSS 31.3338f
C1529 SUM_N_D_3 VSS 26.9477f
C1530 TMDS_TAIL_3 VSS 25.6053f
C1531 SUM_N_D_6 VSS 27.0288f
C1532 SUM_P_D_6 VSS 28.4383f
C1533 TMDS_TAIL_6 VSS 24.8321f
C1534 SUM_N_D_5 VSS 32.2003f
C1535 SUM_P_D_5 VSS 32.7963f
C1536 TMDS_TAIL_5 VSS 31.8882f
C1537 DETECT_ENABLE_B VSS 13.9915f
C1538 SUM_N_D_7 VSS 29.8292f
C1539 SUM_P_D_7 VSS 43.4532f
C1540 TMDS_TAIL_7 VSS 32.6656f
C1541 DETECT_BLEED_5 VSS 6.27397f
C1542 DETECT_BLEED_4 VSS 5.24176f
C1543 DETECT_BLEED_3 VSS 4.65114f
C1544 DETECT_BLEED_2 VSS 4.07108f
C1545 DETECT_BLEED_1 VSS 3.69974f
C1546 DETECT_BLEED_0 VSS 3.57082f
C1547 DETECT_ENABLE_LOCAL VSS 28.7691f
C1548 TERM_BLEED_0 VSS 4.48183f
C1549 TERM_ENABLE_B VSS 8.09144f
C1550 DETECT_BLEED_6 VSS 8.33073f
C1551 TERM_BLEED_6 VSS 3.82986f
C1552 TERM_BLEED_5 VSS 3.0196f
C1553 TERM_BLEED_4 VSS 4.13774f
C1554 TERM_BLEED_3 VSS 6.96254f
C1555 TERM_BLEED_2 VSS 9.91735f
C1556 TERM_BLEED_1 VSS 8.53462f
C1557 TERM_P_R VSS 0.15619p
C1558 DETECT_N_I VSS 10.413f
C1559 DETECT_P_I VSS 14.0036f
C1560 TERM_N_R VSS 0.14233p
C1561 TERM_ENABLE_LOCAL VSS 31.1866f
DWELL_ARRAY VSS ESD_RAIL diode_nw2ps_06v0 area=569.4528p pj=470.72u
.ends

.lib /home/ubuntu/svalbard/scratch/transceiver-pad-pdk/ngspice/sm141064.ngspice diode_typical
.lib /home/ubuntu/svalbard/scratch/transceiver-pad-pdk/ngspice/sm141064.ngspice mimcap_typical
