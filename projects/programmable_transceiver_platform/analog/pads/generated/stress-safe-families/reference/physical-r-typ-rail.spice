.subckt tx_protected_pad PAD_P PAD_N VSS VCM DVDD
XPHYSICAL PAD_P PAD_N VSS VCM DVDD combined_flat
* under-rail capacitance (mkrail.py): with rail cell {'PAD_P': 632.3307299999999, 'PAD_N': 618.0767000000001}, cell alone {'PAD_P': 433.55370999999997, 'PAD_N': 419.29968}
CRAIL_P PAD_P VSS 198.78f
CRAIL_N PAD_N VSS 198.78f
.ends tx_protected_pad
* NGSPICE file created from combined_flat.ext - technology: gf180mcuD

.subckt combined_flat PAD_P PAD_N VSS VCM DVDD
D0 PAD_N__up0 DVDD__kN diode_pd2nw_06v0 pj=51.8u area=22.5p
D1 VSS__aN PAD_N__dn0 diode_nd2ps_06v0 pj=51.8u area=22.5p
X0 BIAS_N_5 BIAS_N_6 VSS ppolyf_u_1k r_width=1u r_length=12.5u
D2 PAD_P__up0 DVDD__kP diode_pd2nw_06v0 pj=51.8u area=22.5p
D3 PAD_N__up1 DVDD__kN diode_pd2nw_06v0 pj=51.8u area=22.5p
D4 VSS__aP PAD_P__dn0 diode_nd2ps_06v0 pj=51.8u area=22.5p
D5 VSS__aN PAD_N__dn1 diode_nd2ps_06v0 pj=51.8u area=22.5p
D6 PAD_P__up1 DVDD__kP diode_pd2nw_06v0 pj=51.8u area=22.5p
X1 BIAS_N_2 BIAS_N_3 VSS ppolyf_u_1k r_width=1u r_length=12.5u
D7 PAD_P__up2 DVDD__kP diode_pd2nw_06v0 pj=51.8u area=22.5p
D8 PAD_N__up2 DVDD__kN diode_pd2nw_06v0 pj=51.8u area=22.5p
D9 VSS__aP PAD_P__dn1 diode_nd2ps_06v0 pj=51.8u area=22.5p
D10 VSS__aP PAD_P__dn2 diode_nd2ps_06v0 pj=51.8u area=22.5p
X2 BIAS_P_3 BIAS_P_4 VSS ppolyf_u_1k r_width=1u r_length=12.5u
X3 BIAS_P_2 BIAS_P_3 VSS ppolyf_u_1k r_width=1u r_length=12.5u
X4 BIAS_N_4 BIAS_N_5 VSS ppolyf_u_1k r_width=1u r_length=12.5u
D11 PAD_P__up3 DVDD__kP diode_pd2nw_06v0 pj=51.8u area=22.5p
D12 VSS__aN PAD_N__dn2 diode_nd2ps_06v0 pj=51.8u area=22.5p
D13 PAD_P__up4 DVDD__kP diode_pd2nw_06v0 pj=51.8u area=22.5p
D14 PAD_N__up3 DVDD__kN diode_pd2nw_06v0 pj=51.8u area=22.5p
X5 BIAS_P_6 VCM VSS ppolyf_u_1k r_width=1u r_length=12.5u
D15 PAD_N__up4 DVDD__kN diode_pd2nw_06v0 pj=51.8u area=22.5p
X6 BIAS_P_0 BIAS_P_1 VSS ppolyf_u_1k r_width=1u r_length=12.5u
X7 BIAS_P_5 BIAS_P_6 VSS ppolyf_u_1k r_width=1u r_length=12.5u
D16 PAD_N__up5 DVDD__kN diode_pd2nw_06v0 pj=51.8u area=22.5p
X8 BIAS_N_1 BIAS_N_2 VSS ppolyf_u_1k r_width=1u r_length=12.5u
D17 PAD_P__up5 DVDD__kP diode_pd2nw_06v0 pj=51.8u area=22.5p
D18 VSS__aN PAD_N__dn3 diode_nd2ps_06v0 pj=51.8u area=22.5p
X9 BIAS_N_3 BIAS_N_4 VSS ppolyf_u_1k r_width=1u r_length=12.5u
X10 BIAS_P_1 BIAS_P_2 VSS ppolyf_u_1k r_width=1u r_length=12.5u
X11 PAD_P__14 BIAS_P_0 VSS ppolyf_u_1k r_width=1u r_length=12.5u
D19 PAD_P__up6 DVDD__kP diode_pd2nw_06v0 pj=51.8u area=22.5p
D20 VSS__aP PAD_P__dn3 diode_nd2ps_06v0 pj=51.8u area=22.5p
D21 PAD_P__up7 DVDD__kP diode_pd2nw_06v0 pj=51.8u area=22.5p
D22 PAD_N__up6 DVDD__kN diode_pd2nw_06v0 pj=51.8u area=22.5p
X12 BIAS_N_6 VCM VSS ppolyf_u_1k r_width=1u r_length=12.5u
D23 PAD_N__up7 DVDD__kN diode_pd2nw_06v0 pj=51.8u area=22.5p
D24 VSS__aP PAD_P__dn4 diode_nd2ps_06v0 pj=51.8u area=22.5p
D25 VSS__aN PAD_N__dn4 diode_nd2ps_06v0 pj=51.8u area=22.5p
X13 BIAS_N_0 BIAS_N_1 VSS ppolyf_u_1k r_width=1u r_length=12.5u
X14 BIAS_P_4 BIAS_P_5 VSS ppolyf_u_1k r_width=1u r_length=12.5u
X15 PAD_N__14 BIAS_N_0 VSS ppolyf_u_1k r_width=1u r_length=12.5u
C0 PAD_P BIAS_P_3 0.40676f
C1 BIAS_P_2 PAD_N 0.26224f
C2 BIAS_P_2 BIAS_P_4 0.06278f
C3 BIAS_N_6 BIAS_N_3 0.13175f
C4 BIAS_N_6 BIAS_N_5 3.55176f
C5 PAD_P VCM 47.7512f
C6 DVDD PAD_P 60.9948f
C7 VCM BIAS_P_5 0.07484f
C8 PAD_N BIAS_P_6 0.93458f
C9 BIAS_P_0 BIAS_N_0 0.20954f
C10 BIAS_P_4 BIAS_P_6 0.00228f
C11 BIAS_P_0 PAD_N 0.65412f
C12 BIAS_N_0 PAD_N 0.46444f
C13 BIAS_N_1 BIAS_N_0 0.85489f
C14 VCM BIAS_N_4 0.05163f
C15 BIAS_N_1 PAD_N 0.1947f
C16 BIAS_P_2 BIAS_P_1 0.27824f
C17 BIAS_P_4 BIAS_N_0 0.0253f
C18 BIAS_P_4 PAD_N 1.00207f
C19 BIAS_P_4 BIAS_N_1 0.00103f
C20 BIAS_N_0 BIAS_N_2 0.11843f
C21 PAD_N BIAS_N_2 0.41491f
C22 BIAS_N_1 BIAS_N_2 2.38477f
C23 BIAS_N_6 PAD_P 0.23379f
C24 BIAS_N_0 BIAS_N_3 0.09904f
C25 BIAS_N_3 PAD_N 0.2554f
C26 BIAS_N_1 BIAS_N_3 0.0653f
C27 BIAS_P_2 PAD_P 0.23889f
C28 BIAS_N_6 BIAS_N_4 0.0653f
C29 PAD_N BIAS_N_5 0.41491f
C30 BIAS_N_3 BIAS_N_2 3.78393f
C31 BIAS_P_0 BIAS_P_1 3.39678f
C32 BIAS_N_0 BIAS_P_1 0.32139f
C33 PAD_N BIAS_P_1 0.70669f
C34 BIAS_P_4 BIAS_P_1 0.034f
C35 BIAS_P_2 BIAS_P_3 1.71751f
C36 PAD_P BIAS_P_6 0.5037f
C37 BIAS_N_3 BIAS_N_5 0.11974f
C38 BIAS_P_5 BIAS_P_6 1.46515f
C39 BIAS_N_6 VCM 0.17957f
C40 PAD_P BIAS_P_0 1.11529f
C41 PAD_P PAD_N 57.5165f
C42 PAD_P BIAS_N_1 0.23321f
C43 PAD_N BIAS_P_5 0.36873f
C44 BIAS_P_4 PAD_P 0.23948f
C45 PAD_P BIAS_N_2 0.39538f
C46 BIAS_P_4 BIAS_P_5 0.47572f
C47 BIAS_N_0 BIAS_N_4 0.00103f
C48 PAD_N BIAS_N_4 0.1947f
C49 BIAS_P_3 PAD_N 0.50239f
C50 PAD_P BIAS_N_3 0.23379f
C51 PAD_P BIAS_N_5 0.39538f
C52 BIAS_P_4 BIAS_P_3 3.16384f
C53 VCM BIAS_P_6 1.99081f
C54 PAD_P BIAS_P_1 0.30166f
C55 BIAS_N_3 BIAS_N_4 0.6241f
C56 BIAS_P_5 BIAS_P_1 0
C57 VCM PAD_N 0.2522f
C58 BIAS_N_1 VCM 0.05163f
C59 BIAS_N_4 BIAS_N_5 2.15441f
C60 DVDD PAD_N 60.9948f
C61 VCM BIAS_N_2 0.0755f
C62 BIAS_P_3 BIAS_P_1 0.00832f
C63 PAD_P BIAS_P_5 0.24067f
C64 VCM BIAS_N_3 0.04195f
C65 BIAS_N_6 PAD_N 0.2563f
C66 VCM BIAS_N_5 0.0755f
C67 PAD_P BIAS_N_4 0.23321f
C68 PAD_P VSS 0.26252p
C69 PAD_N VSS 0.29391p
C70 VCM VSS 55.8729f
C71 DVDD VSS 0.29085p
C72 BIAS_P_0 VSS 4.67095f
C73 BIAS_P_3 VSS 4.33542f
C74 BIAS_P_2 VSS 4.03008f
C75 BIAS_P_1 VSS 6.04814f
C76 BIAS_P_6 VSS 4.5349f
C77 BIAS_P_5 VSS 4.04847f
C78 BIAS_P_4 VSS 6.30889f
C79 BIAS_N_2 VSS 4.52731f
C80 BIAS_N_1 VSS 4.29251f
C81 BIAS_N_0 VSS 7.62753f
C82 BIAS_N_5 VSS 4.46932f
C83 BIAS_N_4 VSS 4.23742f
C84 BIAS_N_3 VSS 6.90398f
C85 BIAS_N_6 VSS 6.72764f
* netres resistances (typ metal x 1.0): 214 resistors, r_a1
RNR0 PAD_P PAD_P__dn0 0.94451
RNR1 PAD_P PAD_P__dn1 0.954508
RNR2 PAD_P PAD_P__dn2 0.964314
RNR3 PAD_P PAD_P__dn3 0.975775
RNR4 PAD_P PAD_P__dn4 0.992228
RNR5 PAD_P PAD_P__up0 5.21869
RNR6 PAD_P PAD_P__up1 4.66223
RNR7 PAD_P PAD_P__up2 3.80987
RNR8 PAD_P PAD_P__up3 4.12051
RNR9 PAD_P PAD_P__up4 5.57251
RNR10 PAD_P PAD_P__up5 7.26559
RNR11 PAD_P PAD_P__up6 8.90907
RNR12 PAD_P PAD_P__up7 9.95202
RNR13 PAD_P PAD_P__14 161.753
RNR14 PAD_P__dn0 PAD_P__dn1 11.8458
RNR15 PAD_P__dn0 PAD_P__dn2 18.4806
RNR16 PAD_P__dn0 PAD_P__dn3 25.6686
RNR17 PAD_P__dn0 PAD_P__dn4 30.3471
RNR18 PAD_P__dn0 PAD_P__up0 58.252
RNR19 PAD_P__dn0 PAD_P__up1 52.0407
RNR20 PAD_P__dn0 PAD_P__up2 42.5265
RNR21 PAD_P__dn0 PAD_P__up3 45.9936
RNR22 PAD_P__dn0 PAD_P__up4 62.2009
RNR23 PAD_P__dn0 PAD_P__up5 81.0992
RNR24 PAD_P__dn0 PAD_P__up6 99.4439
RNR25 PAD_P__dn0 PAD_P__up7 111.085
RNR26 PAD_P__dn0 PAD_P__14 1805.51
RNR27 PAD_P__dn1 PAD_P__dn2 11.8562
RNR28 PAD_P__dn1 PAD_P__dn3 17.0983
RNR29 PAD_P__dn1 PAD_P__dn4 20.4957
RNR30 PAD_P__dn1 PAD_P__up0 94.6589
RNR31 PAD_P__dn1 PAD_P__up1 84.5656
RNR32 PAD_P__dn1 PAD_P__up2 69.1052
RNR33 PAD_P__dn1 PAD_P__up3 74.7392
RNR34 PAD_P__dn1 PAD_P__up4 101.076
RNR35 PAD_P__dn1 PAD_P__up5 131.786
RNR36 PAD_P__dn1 PAD_P__up6 161.595
RNR37 PAD_P__dn1 PAD_P__up7 180.513
RNR38 PAD_P__dn1 PAD_P__14 2933.94
RNR39 PAD_P__dn2 PAD_P__dn3 10.611
RNR40 PAD_P__dn2 PAD_P__dn4 13.084
RNR41 PAD_P__dn2 PAD_P__up0 142.724
RNR42 PAD_P__dn2 PAD_P__up1 127.506
RNR43 PAD_P__dn2 PAD_P__up2 104.195
RNR44 PAD_P__dn2 PAD_P__up3 112.69
RNR45 PAD_P__dn2 PAD_P__up4 152.4
RNR46 PAD_P__dn2 PAD_P__up5 198.703
RNR47 PAD_P__dn2 PAD_P__up6 243.65
RNR48 PAD_P__dn2 PAD_P__up7 272.173
RNR49 PAD_P__dn2 PAD_P__14 4423.72
RNR50 PAD_P__dn3 PAD_P__dn4 7.94347
RNR51 PAD_P__dn3 PAD_P__up0 194.976
RNR52 PAD_P__dn3 PAD_P__up1 174.186
RNR53 PAD_P__dn3 PAD_P__up2 142.341
RNR54 PAD_P__dn3 PAD_P__up3 153.946
RNR55 PAD_P__dn3 PAD_P__up4 208.194
RNR56 PAD_P__dn3 PAD_P__up5 271.449
RNR57 PAD_P__dn3 PAD_P__up6 332.851
RNR58 PAD_P__dn3 PAD_P__up7 371.817
RNR59 PAD_P__dn3 PAD_P__14 6043.27
RNR60 PAD_P__dn4 PAD_P__up0 229.086
RNR61 PAD_P__dn4 PAD_P__up1 204.659
RNR62 PAD_P__dn4 PAD_P__up2 167.243
RNR63 PAD_P__dn4 PAD_P__up3 180.879
RNR64 PAD_P__dn4 PAD_P__up4 244.617
RNR65 PAD_P__dn4 PAD_P__up5 318.938
RNR66 PAD_P__dn4 PAD_P__up6 391.082
RNR67 PAD_P__dn4 PAD_P__up7 436.865
RNR68 PAD_P__dn4 PAD_P__14 7100.51
RNR69 PAD_P__up0 PAD_P__up1 3.14836
RNR70 PAD_P__up0 PAD_P__up2 4.4373
RNR71 PAD_P__up0 PAD_P__up3 10.0546
RNR72 PAD_P__up0 PAD_P__up4 13.5977
RNR73 PAD_P__up0 PAD_P__up5 17.729
RNR74 PAD_P__up0 PAD_P__up6 21.7393
RNR75 PAD_P__up0 PAD_P__up7 24.2842
RNR76 PAD_P__up0 PAD_P__14 329.67
RNR77 PAD_P__up1 PAD_P__up2 3.96416
RNR78 PAD_P__up1 PAD_P__up3 8.9825
RNR79 PAD_P__up1 PAD_P__up4 12.1478
RNR80 PAD_P__up1 PAD_P__up5 15.8386
RNR81 PAD_P__up1 PAD_P__up6 19.4213
RNR82 PAD_P__up1 PAD_P__up7 21.6949
RNR83 PAD_P__up1 PAD_P__14 294.518
RNR84 PAD_P__up2 PAD_P__up3 7.3403
RNR85 PAD_P__up2 PAD_P__up4 9.92689
RNR86 PAD_P__up2 PAD_P__up5 12.943
RNR87 PAD_P__up2 PAD_P__up6 15.8707
RNR88 PAD_P__up2 PAD_P__up7 17.7286
RNR89 PAD_P__up2 PAD_P__14 240.674
RNR90 PAD_P__up3 PAD_P__up4 4.79578
RNR91 PAD_P__up3 PAD_P__up5 6.25287
RNR92 PAD_P__up3 PAD_P__up6 7.66728
RNR93 PAD_P__up3 PAD_P__up7 8.56486
RNR94 PAD_P__up3 PAD_P__14 260.297
RNR95 PAD_P__up4 PAD_P__up5 4.48464
RNR96 PAD_P__up4 PAD_P__up6 5.49907
RNR97 PAD_P__up4 PAD_P__up7 6.14283
RNR98 PAD_P__up4 PAD_P__14 352.021
RNR99 PAD_P__up5 PAD_P__up6 3.92191
RNR100 PAD_P__up5 PAD_P__up7 4.38104
RNR101 PAD_P__up5 PAD_P__14 458.975
RNR102 PAD_P__up6 PAD_P__up7 3.1156
RNR103 PAD_P__up6 PAD_P__14 562.795
RNR104 PAD_P__up7 PAD_P__14 628.68
RNR105 PAD_N PAD_N__dn0 0.944516
RNR106 PAD_N PAD_N__dn1 0.954513
RNR107 PAD_N PAD_N__dn2 0.964318
RNR108 PAD_N PAD_N__dn3 0.975778
RNR109 PAD_N PAD_N__dn4 0.992231
RNR110 PAD_N PAD_N__up0 5.21573
RNR111 PAD_N PAD_N__up1 4.65959
RNR112 PAD_N PAD_N__up2 3.8007
RNR113 PAD_N PAD_N__up3 4.12086
RNR114 PAD_N PAD_N__up4 5.57297
RNR115 PAD_N PAD_N__up5 7.26619
RNR116 PAD_N PAD_N__up6 8.90981
RNR117 PAD_N PAD_N__up7 9.95285
RNR118 PAD_N PAD_N__14 184.292
RNR119 PAD_N__dn0 PAD_N__dn1 11.8458
RNR120 PAD_N__dn0 PAD_N__dn2 18.4805
RNR121 PAD_N__dn0 PAD_N__dn3 25.6684
RNR122 PAD_N__dn0 PAD_N__dn4 30.3469
RNR123 PAD_N__dn0 PAD_N__up0 58.2182
RNR124 PAD_N__dn0 PAD_N__up1 52.0105
RNR125 PAD_N__dn0 PAD_N__up2 42.4235
RNR126 PAD_N__dn0 PAD_N__up3 45.9968
RNR127 PAD_N__dn0 PAD_N__up4 62.2052
RNR128 PAD_N__dn0 PAD_N__up5 81.1048
RNR129 PAD_N__dn0 PAD_N__up6 99.4507
RNR130 PAD_N__dn0 PAD_N__up7 111.093
RNR131 PAD_N__dn0 PAD_N__14 2057.07
RNR132 PAD_N__dn1 PAD_N__dn2 11.8562
RNR133 PAD_N__dn1 PAD_N__dn3 17.0982
RNR134 PAD_N__dn1 PAD_N__dn4 20.4956
RNR135 PAD_N__dn1 PAD_N__up0 94.6037
RNR136 PAD_N__dn1 PAD_N__up1 84.5163
RNR137 PAD_N__dn1 PAD_N__up2 68.9376
RNR138 PAD_N__dn1 PAD_N__up3 74.7442
RNR139 PAD_N__dn1 PAD_N__up4 101.083
RNR140 PAD_N__dn1 PAD_N__up5 131.794
RNR141 PAD_N__dn1 PAD_N__up6 161.606
RNR142 PAD_N__dn1 PAD_N__up7 180.525
RNR143 PAD_N__dn1 PAD_N__14 3342.71
RNR144 PAD_N__dn2 PAD_N__dn3 10.6109
RNR145 PAD_N__dn2 PAD_N__dn4 13.084
RNR146 PAD_N__dn2 PAD_N__up0 142.641
RNR147 PAD_N__dn2 PAD_N__up1 127.431
RNR148 PAD_N__dn2 PAD_N__up2 103.942
RNR149 PAD_N__dn2 PAD_N__up3 112.697
RNR150 PAD_N__dn2 PAD_N__up4 152.41
RNR151 PAD_N__dn2 PAD_N__up5 198.716
RNR152 PAD_N__dn2 PAD_N__up6 243.665
RNR153 PAD_N__dn2 PAD_N__up7 272.191
RNR154 PAD_N__dn2 PAD_N__14 5040.05
RNR155 PAD_N__dn3 PAD_N__dn4 7.94345
RNR156 PAD_N__dn3 PAD_N__up0 194.862
RNR157 PAD_N__dn3 PAD_N__up1 174.084
RNR158 PAD_N__dn3 PAD_N__up2 141.996
RNR159 PAD_N__dn3 PAD_N__up3 153.956
RNR160 PAD_N__dn3 PAD_N__up4 208.207
RNR161 PAD_N__dn3 PAD_N__up5 271.466
RNR162 PAD_N__dn3 PAD_N__up6 332.872
RNR163 PAD_N__dn3 PAD_N__up7 371.84
RNR164 PAD_N__dn3 PAD_N__14 6885.22
RNR165 PAD_N__dn4 PAD_N__up0 228.952
RNR166 PAD_N__dn4 PAD_N__up1 204.539
RNR167 PAD_N__dn4 PAD_N__up2 166.837
RNR168 PAD_N__dn4 PAD_N__up3 180.89
RNR169 PAD_N__dn4 PAD_N__up4 244.632
RNR170 PAD_N__dn4 PAD_N__up5 318.958
RNR171 PAD_N__dn4 PAD_N__up6 391.106
RNR172 PAD_N__dn4 PAD_N__up7 436.892
RNR173 PAD_N__dn4 PAD_N__14 8089.75
RNR174 PAD_N__up0 PAD_N__up1 3.14534
RNR175 PAD_N__up0 PAD_N__up2 4.44832
RNR176 PAD_N__up0 PAD_N__up3 10.0477
RNR177 PAD_N__up0 PAD_N__up4 13.5884
RNR178 PAD_N__up0 PAD_N__up5 17.7169
RNR179 PAD_N__up0 PAD_N__up6 21.7244
RNR180 PAD_N__up0 PAD_N__up7 24.2677
RNR181 PAD_N__up0 PAD_N__14 375.305
RNR182 PAD_N__up1 PAD_N__up2 3.97401
RNR183 PAD_N__up1 PAD_N__up3 8.97636
RNR184 PAD_N__up1 PAD_N__up4 12.1395
RNR185 PAD_N__up1 PAD_N__up5 15.8278
RNR186 PAD_N__up1 PAD_N__up6 19.408
RNR187 PAD_N__up1 PAD_N__up7 21.68
RNR188 PAD_N__up1 PAD_N__14 335.287
RNR189 PAD_N__up2 PAD_N__up3 7.32177
RNR190 PAD_N__up2 PAD_N__up4 9.90183
RNR191 PAD_N__up2 PAD_N__up5 12.9103
RNR192 PAD_N__up2 PAD_N__up6 15.8306
RNR193 PAD_N__up2 PAD_N__up7 17.6838
RNR194 PAD_N__up2 PAD_N__14 273.484
RNR195 PAD_N__up3 PAD_N__up4 4.79576
RNR196 PAD_N__up3 PAD_N__up5 6.25284
RNR197 PAD_N__up3 PAD_N__up6 7.66724
RNR198 PAD_N__up3 PAD_N__up7 8.56482
RNR199 PAD_N__up3 PAD_N__14 296.522
RNR200 PAD_N__up4 PAD_N__up5 4.48463
RNR201 PAD_N__up4 PAD_N__up6 5.49906
RNR202 PAD_N__up4 PAD_N__up7 6.14282
RNR203 PAD_N__up4 PAD_N__14 401.011
RNR204 PAD_N__up5 PAD_N__up6 3.9219
RNR205 PAD_N__up5 PAD_N__up7 4.38103
RNR206 PAD_N__up5 PAD_N__14 522.849
RNR207 PAD_N__up6 PAD_N__up7 3.1156
RNR208 PAD_N__up6 PAD_N__14 641.117
RNR209 PAD_N__up7 PAD_N__14 716.171
RSVSS_P VSS__aP VSS 0.03479
RSVDD_P DVDD__kP DVDD 0.08904
RSVSS_N VSS__aN VSS 0.03479
RSVDD_N DVDD__kN DVDD 0.08904
.ends

.lib /home/ubuntu/svalbard/scratch/transceiver-pad-pdk/ngspice/sm141064.ngspice diode_typical
.lib /home/ubuntu/svalbard/scratch/transceiver-pad-pdk/ngspice/sm141064.ngspice mimcap_typical
