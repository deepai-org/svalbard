.subckt tx_protected_pad PAD_P PAD_N VSS VCM ATB_ESD_RAIL
XPHYSICAL PAD_P PAD_N VSS VCM ESD_RAIL ATB_ESD_RAIL combined_flat
.ends tx_protected_pad
* NGSPICE file created from combined_flat.ext - technology: gf180mcuD

.subckt combined_flat PAD_P PAD_N VSS VCM ESD_RAIL ATB_ESD_RAIL
X0 a_17684_168611# ESD_RAIL ESD_RAIL VSS nfet_06v0 ad=13p pd=50.52u as=13p ps=50.52u w=50u l=0.7u
X1 ESD_RAIL ESD_RAIL a_17684_168611# VSS nfet_06v0 ad=13p pd=50.52u as=13p ps=50.52u w=50u l=0.7u
X2 a_17684_168611# a_17684_168611# a_17684_180275# VSS nfet_06v0 ad=13p pd=50.52u as=13p ps=50.52u w=50u l=0.7u
X3 a_17684_168611# ESD_RAIL ESD_RAIL VSS nfet_06v0 ad=13p pd=50.52u as=13p ps=50.52u w=50u l=0.7u
X4 a_17684_180275# a_17684_168611# a_17684_168611# VSS nfet_06v0 ad=13p pd=50.52u as=13p ps=50.52u w=50u l=0.7u
X5 ESD_RAIL ESD_RAIL a_17684_168611# VSS nfet_06v0 ad=13p pd=50.52u as=13p ps=50.52u w=50u l=0.7u
X6 a_17684_168611# ESD_RAIL ESD_RAIL VSS nfet_06v0 ad=13p pd=50.52u as=13p ps=50.52u w=50u l=0.7u
X7 ESD_RAIL ESD_RAIL a_17684_168611# VSS nfet_06v0 ad=13p pd=50.52u as=13p ps=50.52u w=50u l=0.7u
X8 a_17684_180275# a_17684_180275# VSS VSS nfet_06v0 ad=13p pd=50.52u as=13p ps=50.52u w=50u l=0.7u
X9 a_17684_168611# a_17684_168611# a_17684_180275# VSS nfet_06v0 ad=13p pd=50.52u as=13p ps=50.52u w=50u l=0.7u
X10 a_17005_151825# a_29878_151545# ESD_RAIL ppolyf_u r_width=0.8u r_length=63.855u
X11 a_17684_180275# a_17684_168611# a_17684_168611# VSS nfet_06v0 ad=13p pd=50.52u as=13p ps=50.52u w=50u l=0.7u
X12 a_17684_168611# ESD_RAIL ESD_RAIL VSS nfet_06v0 ad=13p pd=50.52u as=13p ps=50.52u w=50u l=0.7u
X13 VSS a_17684_180275# a_17684_180275# VSS nfet_06v0 ad=13p pd=50.52u as=13p ps=50.52u w=50u l=0.7u
X14 a_17684_168611# ESD_RAIL ESD_RAIL VSS nfet_06v0 ad=13p pd=50.52u as=13p ps=50.52u w=50u l=0.7u
X15 a_17684_180275# a_17684_180275# VSS VSS nfet_06v0 ad=13p pd=50.52u as=13p ps=50.52u w=50u l=0.7u
X16 a_17684_168611# a_17684_168611# a_17684_180275# VSS nfet_06v0 ad=13p pd=50.52u as=13p ps=50.52u w=50u l=0.7u
X17 ESD_RAIL ESD_RAIL a_17684_168611# VSS nfet_06v0 ad=13p pd=50.52u as=13p ps=50.52u w=50u l=0.7u
X18 a_17684_180275# a_17684_168611# a_17684_168611# VSS nfet_06v0 ad=13p pd=50.52u as=13p ps=50.52u w=50u l=0.7u
X19 a_17684_180275# a_17684_168611# a_17684_168611# VSS nfet_06v0 ad=13p pd=50.52u as=13p ps=50.52u w=50u l=0.7u
X20 a_17684_168611# a_17684_168611# a_17684_180275# VSS nfet_06v0 ad=13p pd=50.52u as=13p ps=50.52u w=50u l=0.7u
X21 ESD_RAIL a_20789_137064# a_18245_110628# ESD_RAIL pfet_06v0 ad=1.3p pd=5.52u as=1.3p ps=5.52u w=5u l=0.7u
X22 a_17684_180275# a_17684_180275# VSS VSS nfet_06v0 ad=13p pd=50.52u as=13p ps=50.52u w=50u l=0.7u
X23 a_17684_180275# a_17684_168611# a_17684_168611# VSS nfet_06v0 ad=13p pd=50.52u as=13p ps=50.52u w=50u l=0.7u
X24 a_17684_168611# ESD_RAIL ESD_RAIL VSS nfet_06v0 ad=13p pd=50.52u as=13p ps=50.52u w=50u l=0.7u
X25 a_17684_168611# a_17684_168611# a_17684_180275# VSS nfet_06v0 ad=13p pd=50.52u as=13p ps=50.52u w=50u l=0.7u
X26 ESD_RAIL ESD_RAIL a_17684_168611# VSS nfet_06v0 ad=13p pd=50.52u as=13p ps=50.52u w=50u l=0.7u
X27 ESD_RAIL a_18245_110628# VSS VSS nfet_06v0 ad=13p pd=50.52u as=13p ps=50.52u w=50u l=0.7u
X28 a_17684_168611# ESD_RAIL ESD_RAIL VSS nfet_06v0 ad=13p pd=50.52u as=13p ps=50.52u w=50u l=0.7u
X29 a_17684_180275# a_17684_168611# a_17684_168611# VSS nfet_06v0 ad=13p pd=50.52u as=13p ps=50.52u w=50u l=0.7u
X30 a_17684_180275# a_17684_180275# VSS VSS nfet_06v0 ad=13p pd=50.52u as=13p ps=50.52u w=50u l=0.7u
X31 a_17684_168611# a_17684_168611# a_17684_180275# VSS nfet_06v0 ad=13p pd=50.52u as=13p ps=50.52u w=50u l=0.7u
X32 ESD_RAIL ESD_RAIL a_17684_168611# VSS nfet_06v0 ad=13p pd=50.52u as=13p ps=50.52u w=50u l=0.7u
X33 a_17684_180275# a_17684_168611# a_17684_168611# VSS nfet_06v0 ad=13p pd=50.52u as=13p ps=50.52u w=50u l=0.7u
X34 ESD_RAIL a_18245_110628# VSS VSS nfet_06v0 ad=13p pd=50.52u as=13p ps=50.52u w=50u l=0.7u
X35 VSS a_17684_180275# a_17684_180275# VSS nfet_06v0 ad=13p pd=50.52u as=13p ps=50.52u w=50u l=0.7u
X36 a_20789_137064# a_19813_137064# VSS VSS nfet_06v0 ad=1.3p pd=5.52u as=1.3p ps=5.52u w=5u l=0.7u
X37 a_17684_168611# a_17684_168611# a_17684_180275# VSS nfet_06v0 ad=13p pd=50.52u as=13p ps=50.52u w=50u l=0.7u
X38 VSS a_18245_110628# ESD_RAIL VSS nfet_06v0 ad=13p pd=50.52u as=13p ps=50.52u w=50u l=0.7u
X39 a_17684_180275# a_17684_168611# a_17684_168611# VSS nfet_06v0 ad=13p pd=50.52u as=13p ps=50.52u w=50u l=0.7u
X40 ESD_RAIL ESD_RAIL a_17684_168611# VSS nfet_06v0 ad=13p pd=50.52u as=13p ps=50.52u w=50u l=0.7u
X41 a_17684_168611# a_17684_168611# a_17684_180275# VSS nfet_06v0 ad=13p pd=50.52u as=13p ps=50.52u w=50u l=0.7u
X42 a_17684_180275# a_17684_168611# a_17684_168611# VSS nfet_06v0 ad=13p pd=50.52u as=13p ps=50.52u w=50u l=0.7u
X43 a_17684_168611# ESD_RAIL ESD_RAIL VSS nfet_06v0 ad=13p pd=50.52u as=13p ps=50.52u w=50u l=0.7u
X44 VSS a_17684_180275# a_17684_180275# VSS nfet_06v0 ad=13p pd=50.52u as=13p ps=50.52u w=50u l=0.7u
X45 VSS a_17684_180275# a_17684_180275# VSS nfet_06v0 ad=13p pd=50.52u as=13p ps=50.52u w=50u l=0.7u
X46 a_17005_152945# a_29878_152665# ESD_RAIL ppolyf_u r_width=0.8u r_length=63.855u
X47 ESD_RAIL ESD_RAIL a_17684_168611# VSS nfet_06v0 ad=13p pd=50.52u as=13p ps=50.52u w=50u l=0.7u
X48 a_17684_168611# a_17684_168611# a_17684_180275# VSS nfet_06v0 ad=13p pd=50.52u as=13p ps=50.52u w=50u l=0.7u
X49 a_17684_180275# a_17684_168611# a_17684_168611# VSS nfet_06v0 ad=13p pd=50.52u as=13p ps=50.52u w=50u l=0.7u
X50 a_17684_180275# a_17684_168611# a_17684_168611# VSS nfet_06v0 ad=13p pd=50.52u as=13p ps=50.52u w=50u l=0.7u
X51 ESD_RAIL a_18245_110628# VSS VSS nfet_06v0 ad=13p pd=50.52u as=13p ps=50.52u w=50u l=0.7u
X52 ESD_RAIL ESD_RAIL a_17684_168611# VSS nfet_06v0 ad=13p pd=50.52u as=13p ps=50.52u w=50u l=0.7u
X53 a_17684_180275# a_17684_168611# a_17684_168611# VSS nfet_06v0 ad=13p pd=50.52u as=13p ps=50.52u w=50u l=0.7u
X54 a_17684_168611# a_17684_168611# a_17684_180275# VSS nfet_06v0 ad=13p pd=50.52u as=13p ps=50.52u w=50u l=0.7u
X55 a_17684_180275# a_17684_168611# a_17684_168611# VSS nfet_06v0 ad=13p pd=50.52u as=13p ps=50.52u w=50u l=0.7u
X56 a_17684_168611# a_17684_168611# a_17684_180275# VSS nfet_06v0 ad=13p pd=50.52u as=13p ps=50.52u w=50u l=0.7u
X57 a_17684_180275# a_17684_180275# VSS VSS nfet_06v0 ad=13p pd=50.52u as=13p ps=50.52u w=50u l=0.7u
X58 a_17684_180275# a_17684_180275# VSS VSS nfet_06v0 ad=13p pd=50.52u as=13p ps=50.52u w=50u l=0.7u
X59 VSS a_18245_110628# ESD_RAIL VSS nfet_06v0 ad=13p pd=50.52u as=13p ps=50.52u w=50u l=0.7u
X60 a_17684_180275# a_17684_168611# a_17684_168611# VSS nfet_06v0 ad=13p pd=50.52u as=13p ps=50.52u w=50u l=0.7u
X61 VSS a_17684_180275# a_17684_180275# VSS nfet_06v0 ad=13p pd=50.52u as=13p ps=50.52u w=50u l=0.7u
X62 ESD_RAIL ESD_RAIL a_17684_168611# VSS nfet_06v0 ad=13p pd=50.52u as=13p ps=50.52u w=50u l=0.7u
X63 VSS a_18245_110628# ESD_RAIL VSS nfet_06v0 ad=13p pd=50.52u as=22p ps=0.10088m w=50u l=0.7u
X64 a_17684_180275# a_17684_180275# VSS VSS nfet_06v0 ad=13p pd=50.52u as=13p ps=50.52u w=50u l=0.7u
X65 a_17684_168611# ESD_RAIL ESD_RAIL VSS nfet_06v0 ad=13p pd=50.52u as=13p ps=50.52u w=50u l=0.7u
X66 VSS a_17684_180275# a_17684_180275# VSS nfet_06v0 ad=13p pd=50.52u as=13p ps=50.52u w=50u l=0.7u
X67 VSS a_17684_180275# a_17684_180275# VSS nfet_06v0 ad=13p pd=50.52u as=13p ps=50.52u w=50u l=0.7u
X68 VSS a_17684_180275# a_17684_180275# VSS nfet_06v0 ad=13p pd=50.52u as=13p ps=50.52u w=50u l=0.7u
X69 a_17684_180275# a_17684_180275# VSS VSS nfet_06v0 ad=13p pd=50.52u as=13p ps=50.52u w=50u l=0.7u
X70 VSS a_18245_110628# ESD_RAIL VSS nfet_06v0 ad=13p pd=50.52u as=22p ps=0.10088m w=50u l=0.7u
X71 a_18245_110628# a_20789_137064# ESD_RAIL ESD_RAIL pfet_06v0 ad=1.3p pd=5.52u as=1.3p ps=5.52u w=5u l=0.7u
X72 a_17684_180275# a_17684_168611# a_17684_168611# VSS nfet_06v0 ad=13p pd=50.52u as=13p ps=50.52u w=50u l=0.7u
X73 VSS a_17684_180275# a_17684_180275# VSS nfet_06v0 ad=13p pd=50.52u as=13p ps=50.52u w=50u l=0.7u
X74 a_17684_168611# ESD_RAIL ESD_RAIL VSS nfet_06v0 ad=13p pd=50.52u as=13p ps=50.52u w=50u l=0.7u
X75 VSS a_17684_180275# a_17684_180275# VSS nfet_06v0 ad=13p pd=50.52u as=13p ps=50.52u w=50u l=0.7u
X76 a_17684_180275# a_17684_180275# VSS VSS nfet_06v0 ad=13p pd=50.52u as=13p ps=50.52u w=50u l=0.7u
X77 a_17684_168611# ESD_RAIL ESD_RAIL VSS nfet_06v0 ad=13p pd=50.52u as=13p ps=50.52u w=50u l=0.7u
X78 VSS a_17684_180275# a_17684_180275# VSS nfet_06v0 ad=13p pd=50.52u as=13p ps=50.52u w=50u l=0.7u
X79 a_17684_180275# a_17684_180275# VSS VSS nfet_06v0 ad=13p pd=50.52u as=13p ps=50.52u w=50u l=0.7u
X80 VSS a_17684_180275# a_17684_180275# VSS nfet_06v0 ad=13p pd=50.52u as=13p ps=50.52u w=50u l=0.7u
X81 a_17684_180275# a_17684_180275# VSS VSS nfet_06v0 ad=13p pd=50.52u as=13p ps=50.52u w=50u l=0.7u
X82 VSS a_17684_180275# a_17684_180275# VSS nfet_06v0 ad=13p pd=50.52u as=13p ps=50.52u w=50u l=0.7u
X83 a_17684_180275# a_17684_180275# VSS VSS nfet_06v0 ad=13p pd=50.52u as=13p ps=50.52u w=50u l=0.7u
X84 VSS a_17684_180275# a_17684_180275# VSS nfet_06v0 ad=13p pd=50.52u as=13p ps=50.52u w=50u l=0.7u
X85 a_17684_180275# a_17684_180275# VSS VSS nfet_06v0 ad=13p pd=50.52u as=22p ps=0.10088m w=50u l=0.7u
X86 a_17684_168611# a_17684_168611# a_17684_180275# VSS nfet_06v0 ad=13p pd=50.52u as=13p ps=50.52u w=50u l=0.7u
X87 VSS a_18245_110628# ESD_RAIL VSS nfet_06v0 ad=13p pd=50.52u as=13p ps=50.52u w=50u l=0.7u
X88 a_17684_180275# a_17684_180275# VSS VSS nfet_06v0 ad=13p pd=50.52u as=13p ps=50.52u w=50u l=0.7u
X89 VSS a_17684_180275# a_17684_180275# VSS nfet_06v0 ad=13p pd=50.52u as=13p ps=50.52u w=50u l=0.7u
X90 ESD_RAIL a_18245_110628# VSS VSS nfet_06v0 ad=13p pd=50.52u as=13p ps=50.52u w=50u l=0.7u
X91 ESD_RAIL ESD_RAIL a_17684_168611# VSS nfet_06v0 ad=13p pd=50.52u as=13p ps=50.52u w=50u l=0.7u
X92 a_17684_168611# a_17684_168611# a_17684_180275# VSS nfet_06v0 ad=13p pd=50.52u as=13p ps=50.52u w=50u l=0.7u
X93 ESD_RAIL a_20789_137064# a_18245_110628# ESD_RAIL pfet_06v0 ad=1.3p pd=5.52u as=1.3p ps=5.52u w=5u l=0.7u
X94 ESD_RAIL ESD_RAIL a_17684_168611# VSS nfet_06v0 ad=13p pd=50.52u as=13p ps=50.52u w=50u l=0.7u
D0 VSS PAD_N diode_nd2ps_06v0 pj=51.8u area=22.5p
X95 ESD_RAIL a_18245_110628# VSS VSS nfet_06v0 ad=13p pd=50.52u as=13p ps=50.52u w=50u l=0.7u
X96 a_17684_180275# a_17684_180275# VSS VSS nfet_06v0 ad=13p pd=50.52u as=13p ps=50.52u w=50u l=0.7u
X97 BIAS_N_1 BIAS_N_2 VSS ppolyf_u_1k r_width=1u r_length=12.5u
X98 a_17684_168611# ESD_RAIL ESD_RAIL VSS nfet_06v0 ad=13p pd=50.52u as=13p ps=50.52u w=50u l=0.7u
X99 VSS a_17684_180275# a_17684_180275# VSS nfet_06v0 ad=13p pd=50.52u as=13p ps=50.52u w=50u l=0.7u
D1 VSS PAD_P diode_nd2ps_06v0 pj=51.8u area=22.5p
X100 ESD_RAIL ESD_RAIL a_17684_168611# VSS nfet_06v0 ad=13p pd=50.52u as=13p ps=50.52u w=50u l=0.7u
X101 a_17684_180275# a_17684_180275# VSS VSS nfet_06v0 ad=13p pd=50.52u as=13p ps=50.52u w=50u l=0.7u
D2 VSS PAD_N diode_nd2ps_06v0 pj=51.8u area=22.5p
X102 a_17684_168611# ESD_RAIL ESD_RAIL VSS nfet_06v0 ad=13p pd=50.52u as=13p ps=50.52u w=50u l=0.7u
X103 VSS a_17684_180275# a_17684_180275# VSS nfet_06v0 ad=13p pd=50.52u as=13p ps=50.52u w=50u l=0.7u
X104 VSS a_17684_180275# a_17684_180275# VSS nfet_06v0 ad=13p pd=50.52u as=13p ps=50.52u w=50u l=0.7u
X105 a_17684_168611# ESD_RAIL ESD_RAIL VSS nfet_06v0 ad=13p pd=50.52u as=13p ps=50.52u w=50u l=0.7u
X106 a_17684_180275# a_17684_180275# VSS VSS nfet_06v0 ad=13p pd=50.52u as=13p ps=50.52u w=50u l=0.7u
X107 a_17684_180275# a_17684_180275# VSS VSS nfet_06v0 ad=13p pd=50.52u as=13p ps=50.52u w=50u l=0.7u
X108 ESD_RAIL ESD_RAIL a_17684_168611# VSS nfet_06v0 ad=13p pd=50.52u as=13p ps=50.52u w=50u l=0.7u
X109 a_17684_168611# ESD_RAIL ESD_RAIL VSS nfet_06v0 ad=13p pd=50.52u as=13p ps=50.52u w=50u l=0.7u
X110 a_17684_180275# a_17684_168611# a_17684_168611# VSS nfet_06v0 ad=13p pd=50.52u as=13p ps=50.52u w=50u l=0.7u
X111 VSS a_17684_180275# a_17684_180275# VSS nfet_06v0 ad=13p pd=50.52u as=13p ps=50.52u w=50u l=0.7u
X112 a_17684_168611# ESD_RAIL ESD_RAIL VSS nfet_06v0 ad=13p pd=50.52u as=13p ps=50.52u w=50u l=0.7u
X113 a_17684_180275# a_17684_180275# VSS VSS nfet_06v0 ad=13p pd=50.52u as=13p ps=50.52u w=50u l=0.7u
X114 ESD_RAIL ESD_RAIL a_17684_168611# VSS nfet_06v0 ad=13p pd=50.52u as=13p ps=50.52u w=50u l=0.7u
X115 a_17684_168611# ESD_RAIL ESD_RAIL VSS nfet_06v0 ad=13p pd=50.52u as=13p ps=50.52u w=50u l=0.7u
X116 a_17684_168611# ESD_RAIL ESD_RAIL VSS nfet_06v0 ad=13p pd=50.52u as=13p ps=50.52u w=50u l=0.7u
X117 VSS a_18245_110628# ESD_RAIL VSS nfet_06v0 ad=13p pd=50.52u as=13p ps=50.52u w=50u l=0.7u
X118 ESD_RAIL a_20789_137064# a_18245_110628# ESD_RAIL pfet_06v0 ad=2.2p pd=10.88u as=1.3p ps=5.52u w=5u l=0.7u
X119 a_17684_168611# ESD_RAIL ESD_RAIL VSS nfet_06v0 ad=13p pd=50.52u as=13p ps=50.52u w=50u l=0.7u
X120 ESD_RAIL ESD_RAIL a_17684_168611# VSS nfet_06v0 ad=13p pd=50.52u as=13p ps=50.52u w=50u l=0.7u
X121 a_17684_180275# a_17684_180275# VSS VSS nfet_06v0 ad=13p pd=50.52u as=13p ps=50.52u w=50u l=0.7u
X122 ESD_RAIL ESD_RAIL a_17684_168611# VSS nfet_06v0 ad=13p pd=50.52u as=13p ps=50.52u w=50u l=0.7u
X123 VSS a_17684_180275# a_17684_180275# VSS nfet_06v0 ad=13p pd=50.52u as=13p ps=50.52u w=50u l=0.7u
X124 a_17684_168611# ESD_RAIL ESD_RAIL VSS nfet_06v0 ad=13p pd=50.52u as=13p ps=50.52u w=50u l=0.7u
X125 ESD_RAIL ESD_RAIL a_17684_168611# VSS nfet_06v0 ad=13p pd=50.52u as=13p ps=50.52u w=50u l=0.7u
X126 a_17684_168611# ESD_RAIL ESD_RAIL VSS nfet_06v0 ad=13p pd=50.52u as=13p ps=50.52u w=50u l=0.7u
X127 VSS a_17684_180275# a_17684_180275# VSS nfet_06v0 ad=13p pd=50.52u as=13p ps=50.52u w=50u l=0.7u
X128 a_17684_180275# a_17684_168611# a_17684_168611# VSS nfet_06v0 ad=13p pd=50.52u as=13p ps=50.52u w=50u l=0.7u
X129 a_17684_180275# a_17684_180275# VSS VSS nfet_06v0 ad=13p pd=50.52u as=13p ps=50.52u w=50u l=0.7u
X130 a_17684_168611# a_17684_168611# a_17684_180275# VSS nfet_06v0 ad=13p pd=50.52u as=13p ps=50.52u w=50u l=0.7u
X131 a_17684_168611# a_17684_168611# a_17684_180275# VSS nfet_06v0 ad=13p pd=50.52u as=13p ps=50.52u w=50u l=0.7u
X132 ESD_RAIL ESD_RAIL a_17684_168611# VSS nfet_06v0 ad=13p pd=50.52u as=22p ps=0.10088m w=50u l=0.7u
X133 a_17684_180275# a_17684_180275# VSS VSS nfet_06v0 ad=13p pd=50.52u as=13p ps=50.52u w=50u l=0.7u
X134 a_17005_154065# a_29878_153785# ESD_RAIL ppolyf_u r_width=0.8u r_length=63.855u
X135 ESD_RAIL ESD_RAIL a_17684_168611# VSS nfet_06v0 ad=13p pd=50.52u as=13p ps=50.52u w=50u l=0.7u
X136 VSS a_17684_180275# a_17684_180275# VSS nfet_06v0 ad=13p pd=50.52u as=13p ps=50.52u w=50u l=0.7u
X137 BIAS_P_3 BIAS_P_4 VSS ppolyf_u_1k r_width=1u r_length=12.5u
X138 a_17684_168611# ESD_RAIL ESD_RAIL VSS nfet_06v0 ad=13p pd=50.52u as=13p ps=50.52u w=50u l=0.7u
X139 ESD_RAIL ESD_RAIL a_17684_168611# VSS nfet_06v0 ad=13p pd=50.52u as=13p ps=50.52u w=50u l=0.7u
X140 ESD_RAIL ESD_RAIL a_17684_168611# VSS nfet_06v0 ad=13p pd=50.52u as=13p ps=50.52u w=50u l=0.7u
X141 a_17684_168611# ESD_RAIL ESD_RAIL VSS nfet_06v0 ad=13p pd=50.52u as=13p ps=50.52u w=50u l=0.7u
X142 a_17684_168611# a_17684_168611# a_17684_180275# VSS nfet_06v0 ad=13p pd=50.52u as=13p ps=50.52u w=50u l=0.7u
X143 VSS a_18245_110628# ESD_RAIL VSS nfet_06v0 ad=13p pd=50.52u as=13p ps=50.52u w=50u l=0.7u
X144 VSS a_18245_110628# ESD_RAIL VSS nfet_06v0 ad=13p pd=50.52u as=13p ps=50.52u w=50u l=0.7u
X145 a_17684_180275# a_17684_168611# a_17684_168611# VSS nfet_06v0 ad=13p pd=50.52u as=13p ps=50.52u w=50u l=0.7u
X146 a_17684_168611# ESD_RAIL ESD_RAIL VSS nfet_06v0 ad=13p pd=50.52u as=13p ps=50.52u w=50u l=0.7u
X147 VSS a_17684_180275# a_17684_180275# VSS nfet_06v0 ad=13p pd=50.52u as=13p ps=50.52u w=50u l=0.7u
X148 VSS a_17684_180275# a_17684_180275# VSS nfet_06v0 ad=13p pd=50.52u as=13p ps=50.52u w=50u l=0.7u
X149 a_17684_168611# ESD_RAIL ESD_RAIL VSS nfet_06v0 ad=13p pd=50.52u as=13p ps=50.52u w=50u l=0.7u
X150 a_17684_180275# a_17684_180275# VSS VSS nfet_06v0 ad=13p pd=50.52u as=13p ps=50.52u w=50u l=0.7u
X151 a_17684_180275# a_17684_180275# VSS VSS nfet_06v0 ad=13p pd=50.52u as=13p ps=50.52u w=50u l=0.7u
X152 ESD_RAIL ESD_RAIL a_17684_168611# VSS nfet_06v0 ad=13p pd=50.52u as=13p ps=50.52u w=50u l=0.7u
X153 ESD_RAIL ESD_RAIL a_17684_168611# VSS nfet_06v0 ad=13p pd=50.52u as=13p ps=50.52u w=50u l=0.7u
D3 VSS ESD_RAIL diode_nd2ps_06v0 pj=82u area=40p
X154 VSS a_17684_180275# a_17684_180275# VSS nfet_06v0 ad=13p pd=50.52u as=13p ps=50.52u w=50u l=0.7u
X155 a_17684_168611# ESD_RAIL ESD_RAIL VSS nfet_06v0 ad=13p pd=50.52u as=13p ps=50.52u w=50u l=0.7u
X156 ESD_RAIL ESD_RAIL a_17684_168611# VSS nfet_06v0 ad=13p pd=50.52u as=13p ps=50.52u w=50u l=0.7u
X157 a_17684_168611# a_17684_168611# a_17684_180275# VSS nfet_06v0 ad=13p pd=50.52u as=13p ps=50.52u w=50u l=0.7u
X158 a_17684_180275# a_17684_168611# a_17684_168611# VSS nfet_06v0 ad=13p pd=50.52u as=13p ps=50.52u w=50u l=0.7u
X159 a_17684_168611# a_17684_168611# a_17684_180275# VSS nfet_06v0 ad=13p pd=50.52u as=13p ps=50.52u w=50u l=0.7u
X160 a_17684_168611# a_17684_168611# a_17684_180275# VSS nfet_06v0 ad=13p pd=50.52u as=13p ps=50.52u w=50u l=0.7u
X161 ESD_RAIL a_18245_110628# VSS VSS nfet_06v0 ad=13p pd=50.52u as=13p ps=50.52u w=50u l=0.7u
X162 ESD_RAIL ESD_RAIL a_17684_168611# VSS nfet_06v0 ad=13p pd=50.52u as=13p ps=50.52u w=50u l=0.7u
X163 a_17684_168611# ESD_RAIL ESD_RAIL VSS nfet_06v0 ad=13p pd=50.52u as=13p ps=50.52u w=50u l=0.7u
X164 a_17684_168611# ESD_RAIL ESD_RAIL VSS nfet_06v0 ad=13p pd=50.52u as=13p ps=50.52u w=50u l=0.7u
X165 a_17684_180275# a_17684_168611# a_17684_168611# VSS nfet_06v0 ad=13p pd=50.52u as=13p ps=50.52u w=50u l=0.7u
X166 a_17684_168611# a_17684_168611# a_17684_180275# VSS nfet_06v0 ad=13p pd=50.52u as=13p ps=50.52u w=50u l=0.7u
X167 a_17684_168611# a_17684_168611# a_17684_180275# VSS nfet_06v0 ad=13p pd=50.52u as=13p ps=50.52u w=50u l=0.7u
X168 ESD_RAIL ESD_RAIL a_17684_168611# VSS nfet_06v0 ad=13p pd=50.52u as=13p ps=50.52u w=50u l=0.7u
X169 a_17684_168611# a_17684_168611# a_17684_180275# VSS nfet_06v0 ad=13p pd=50.52u as=13p ps=50.52u w=50u l=0.7u
X170 ESD_RAIL ESD_RAIL a_17684_168611# VSS nfet_06v0 ad=13p pd=50.52u as=13p ps=50.52u w=50u l=0.7u
X171 a_17684_168611# ESD_RAIL ESD_RAIL VSS nfet_06v0 ad=13p pd=50.52u as=13p ps=50.52u w=50u l=0.7u
X172 a_17684_180275# a_17684_168611# a_17684_168611# VSS nfet_06v0 ad=13p pd=50.52u as=13p ps=50.52u w=50u l=0.7u
X173 a_17684_168611# a_17684_168611# a_17684_180275# VSS nfet_06v0 ad=13p pd=50.52u as=13p ps=50.52u w=50u l=0.7u
X174 ESD_RAIL a_17005_151545# a_19813_137064# ESD_RAIL pfet_06v0 ad=1.3p pd=5.52u as=1.3p ps=5.52u w=5u l=0.7u
X175 a_17684_168611# a_17684_168611# a_17684_180275# VSS nfet_06v0 ad=13p pd=50.52u as=13p ps=50.52u w=50u l=0.7u
X176 a_17684_168611# a_17684_168611# a_17684_180275# VSS nfet_06v0 ad=13p pd=50.52u as=13p ps=50.52u w=50u l=0.7u
X177 ESD_RAIL a_18245_110628# VSS VSS nfet_06v0 ad=13p pd=50.52u as=13p ps=50.52u w=50u l=0.7u
X178 a_19813_137064# a_17005_151545# ESD_RAIL ESD_RAIL pfet_06v0 ad=1.3p pd=5.52u as=2.2p ps=10.88u w=5u l=0.7u
X179 a_17684_180275# a_17684_168611# a_17684_168611# VSS nfet_06v0 ad=13p pd=50.52u as=13p ps=50.52u w=50u l=0.7u
X180 a_17684_180275# a_17684_168611# a_17684_168611# VSS nfet_06v0 ad=13p pd=50.52u as=13p ps=50.52u w=50u l=0.7u
X181 ESD_RAIL a_18245_110628# VSS VSS nfet_06v0 ad=22p pd=0.10088m as=13p ps=50.52u w=50u l=0.7u
X182 a_17684_168611# ESD_RAIL ESD_RAIL VSS nfet_06v0 ad=13p pd=50.52u as=13p ps=50.52u w=50u l=0.7u
X183 a_17684_168611# a_17684_168611# a_17684_180275# VSS nfet_06v0 ad=13p pd=50.52u as=13p ps=50.52u w=50u l=0.7u
X184 a_17684_168611# ESD_RAIL ESD_RAIL VSS nfet_06v0 ad=13p pd=50.52u as=13p ps=50.52u w=50u l=0.7u
X185 a_17684_168611# a_17684_168611# a_17684_180275# VSS nfet_06v0 ad=13p pd=50.52u as=13p ps=50.52u w=50u l=0.7u
X186 ESD_RAIL a_18245_110628# VSS VSS nfet_06v0 ad=13p pd=50.52u as=13p ps=50.52u w=50u l=0.7u
X187 ESD_RAIL ESD_RAIL a_17684_168611# VSS nfet_06v0 ad=13p pd=50.52u as=13p ps=50.52u w=50u l=0.7u
X188 ESD_RAIL ESD_RAIL a_17684_168611# VSS nfet_06v0 ad=13p pd=50.52u as=13p ps=50.52u w=50u l=0.7u
X189 a_17684_180275# a_17684_168611# a_17684_168611# VSS nfet_06v0 ad=13p pd=50.52u as=13p ps=50.52u w=50u l=0.7u
X190 a_17684_168611# ESD_RAIL ESD_RAIL VSS nfet_06v0 ad=13p pd=50.52u as=13p ps=50.52u w=50u l=0.7u
X191 a_17684_180275# a_17684_168611# a_17684_168611# VSS nfet_06v0 ad=13p pd=50.52u as=13p ps=50.52u w=50u l=0.7u
X192 a_17684_168611# a_17684_168611# a_17684_180275# VSS nfet_06v0 ad=13p pd=50.52u as=13p ps=50.52u w=50u l=0.7u
X193 a_17684_168611# a_17684_168611# a_17684_180275# VSS nfet_06v0 ad=13p pd=50.52u as=13p ps=50.52u w=50u l=0.7u
X194 a_17684_180275# a_17684_180275# VSS VSS nfet_06v0 ad=13p pd=50.52u as=13p ps=50.52u w=50u l=0.7u
X195 a_17684_180275# a_17684_168611# a_17684_168611# VSS nfet_06v0 ad=13p pd=50.52u as=13p ps=50.52u w=50u l=0.7u
X196 a_17684_168611# a_17684_168611# a_17684_180275# VSS nfet_06v0 ad=13p pd=50.52u as=13p ps=50.52u w=50u l=0.7u
X197 a_17684_180275# a_17684_168611# a_17684_168611# VSS nfet_06v0 ad=13p pd=50.52u as=13p ps=50.52u w=50u l=0.7u
X198 a_17684_168611# a_17684_168611# a_17684_180275# VSS nfet_06v0 ad=13p pd=50.52u as=13p ps=50.52u w=50u l=0.7u
X199 VSS a_18245_110628# ESD_RAIL VSS nfet_06v0 ad=13p pd=50.52u as=13p ps=50.52u w=50u l=0.7u
X200 a_17684_180275# a_17684_180275# VSS VSS nfet_06v0 ad=13p pd=50.52u as=13p ps=50.52u w=50u l=0.7u
X201 a_17684_180275# a_17684_168611# a_17684_168611# VSS nfet_06v0 ad=13p pd=50.52u as=13p ps=50.52u w=50u l=0.7u
X202 a_17684_168611# a_17684_168611# a_17684_180275# VSS nfet_06v0 ad=13p pd=50.52u as=13p ps=50.52u w=50u l=0.7u
X203 a_17684_180275# a_17684_168611# a_17684_168611# VSS nfet_06v0 ad=13p pd=50.52u as=13p ps=50.52u w=50u l=0.7u
X204 VSS a_17684_180275# a_17684_180275# VSS nfet_06v0 ad=13p pd=50.52u as=13p ps=50.52u w=50u l=0.7u
X205 a_17684_168611# a_17684_168611# a_17684_180275# VSS nfet_06v0 ad=13p pd=50.52u as=13p ps=50.52u w=50u l=0.7u
X206 a_17684_180275# a_17684_168611# a_17684_168611# VSS nfet_06v0 ad=13p pd=50.52u as=13p ps=50.52u w=50u l=0.7u
X207 a_17684_180275# a_17684_168611# a_17684_168611# VSS nfet_06v0 ad=13p pd=50.52u as=13p ps=50.52u w=50u l=0.7u
X208 VSS a_17684_180275# a_17684_180275# VSS nfet_06v0 ad=13p pd=50.52u as=13p ps=50.52u w=50u l=0.7u
X209 a_17684_168611# a_17684_168611# a_17684_180275# VSS nfet_06v0 ad=13p pd=50.52u as=13p ps=50.52u w=50u l=0.7u
X210 VSS a_18245_110628# ESD_RAIL VSS nfet_06v0 ad=13p pd=50.52u as=13p ps=50.52u w=50u l=0.7u
X211 a_17684_180275# a_17684_168611# a_17684_168611# VSS nfet_06v0 ad=13p pd=50.52u as=13p ps=50.52u w=50u l=0.7u
X212 VSS a_18245_110628# ESD_RAIL VSS nfet_06v0 ad=13p pd=50.52u as=22p ps=0.10088m w=50u l=0.7u
X213 VSS a_18245_110628# ESD_RAIL VSS nfet_06v0 ad=13p pd=50.52u as=13p ps=50.52u w=50u l=0.7u
X214 ESD_RAIL a_20789_137064# a_18245_110628# ESD_RAIL pfet_06v0 ad=1.3p pd=5.52u as=1.3p ps=5.52u w=5u l=0.7u
X215 VSS a_17684_180275# a_17684_180275# VSS nfet_06v0 ad=13p pd=50.52u as=13p ps=50.52u w=50u l=0.7u
X216 a_17684_180275# a_17684_180275# VSS VSS nfet_06v0 ad=13p pd=50.52u as=13p ps=50.52u w=50u l=0.7u
X217 a_17684_168611# a_17684_168611# a_17684_180275# VSS nfet_06v0 ad=13p pd=50.52u as=13p ps=50.52u w=50u l=0.7u
X218 a_17684_180275# a_17684_168611# a_17684_168611# VSS nfet_06v0 ad=13p pd=50.52u as=13p ps=50.52u w=50u l=0.7u
X219 a_18245_110628# a_20789_137064# ESD_RAIL ESD_RAIL pfet_06v0 ad=1.3p pd=5.52u as=1.3p ps=5.52u w=5u l=0.7u
X220 VSS a_18245_110628# ESD_RAIL VSS nfet_06v0 ad=13p pd=50.52u as=13p ps=50.52u w=50u l=0.7u
X221 a_17684_168611# a_17684_168611# a_17684_180275# VSS nfet_06v0 ad=13p pd=50.52u as=13p ps=50.52u w=50u l=0.7u
X222 a_17684_180275# a_17684_180275# VSS VSS nfet_06v0 ad=13p pd=50.52u as=13p ps=50.52u w=50u l=0.7u
X223 ESD_RAIL ESD_RAIL a_17684_168611# VSS nfet_06v0 ad=13p pd=50.52u as=13p ps=50.52u w=50u l=0.7u
X224 a_17684_180275# a_17684_168611# a_17684_168611# VSS nfet_06v0 ad=13p pd=50.52u as=13p ps=50.52u w=50u l=0.7u
X225 a_17684_168611# a_17684_168611# a_17684_180275# VSS nfet_06v0 ad=13p pd=50.52u as=13p ps=50.52u w=50u l=0.7u
X226 ESD_RAIL a_18245_110628# VSS VSS nfet_06v0 ad=13p pd=50.52u as=13p ps=50.52u w=50u l=0.7u
X227 a_17684_180275# a_17684_180275# VSS VSS nfet_06v0 ad=13p pd=50.52u as=13p ps=50.52u w=50u l=0.7u
X228 ESD_RAIL ESD_RAIL a_17684_168611# VSS nfet_06v0 ad=13p pd=50.52u as=13p ps=50.52u w=50u l=0.7u
X229 a_17684_180275# a_17684_168611# a_17684_168611# VSS nfet_06v0 ad=13p pd=50.52u as=13p ps=50.52u w=50u l=0.7u
X230 a_17684_168611# a_17684_168611# a_17684_180275# VSS nfet_06v0 ad=13p pd=50.52u as=13p ps=50.52u w=50u l=0.7u
X231 a_17684_168611# a_17684_168611# a_17684_180275# VSS nfet_06v0 ad=13p pd=50.52u as=13p ps=50.52u w=50u l=0.7u
X232 a_18245_110628# a_20789_137064# ESD_RAIL ESD_RAIL pfet_06v0 ad=1.3p pd=5.52u as=1.3p ps=5.52u w=5u l=0.7u
X233 VSS a_17684_180275# a_17684_180275# VSS nfet_06v0 ad=13p pd=50.52u as=13p ps=50.52u w=50u l=0.7u
X234 a_17684_168611# ESD_RAIL ESD_RAIL VSS nfet_06v0 ad=13p pd=50.52u as=13p ps=50.52u w=50u l=0.7u
X235 a_17684_168611# a_17684_168611# a_17684_180275# VSS nfet_06v0 ad=13p pd=50.52u as=13p ps=50.52u w=50u l=0.7u
X236 ESD_RAIL a_20789_137064# a_18245_110628# ESD_RAIL pfet_06v0 ad=1.3p pd=5.52u as=1.3p ps=5.52u w=5u l=0.7u
X237 VSS a_17684_180275# a_17684_180275# VSS nfet_06v0 ad=13p pd=50.52u as=13p ps=50.52u w=50u l=0.7u
X238 VSS a_17684_180275# a_17684_180275# VSS nfet_06v0 ad=13p pd=50.52u as=13p ps=50.52u w=50u l=0.7u
D4 VSS PAD_P diode_nd2ps_06v0 pj=51.8u area=22.5p
X239 a_17684_168611# ESD_RAIL ESD_RAIL VSS nfet_06v0 ad=13p pd=50.52u as=13p ps=50.52u w=50u l=0.7u
X240 a_17684_168611# a_17684_168611# a_17684_180275# VSS nfet_06v0 ad=13p pd=50.52u as=13p ps=50.52u w=50u l=0.7u
X241 ESD_RAIL a_18245_110628# VSS VSS nfet_06v0 ad=13p pd=50.52u as=13p ps=50.52u w=50u l=0.7u
X242 a_17684_168611# ESD_RAIL ESD_RAIL VSS nfet_06v0 ad=13p pd=50.52u as=13p ps=50.52u w=50u l=0.7u
X243 VSS a_17684_180275# a_17684_180275# VSS nfet_06v0 ad=13p pd=50.52u as=13p ps=50.52u w=50u l=0.7u
X244 ESD_RAIL ESD_RAIL a_17684_168611# VSS nfet_06v0 ad=13p pd=50.52u as=13p ps=50.52u w=50u l=0.7u
X245 ESD_RAIL a_20789_137064# a_18245_110628# ESD_RAIL pfet_06v0 ad=1.3p pd=5.52u as=1.3p ps=5.52u w=5u l=0.7u
X246 a_17684_180275# a_17684_180275# VSS VSS nfet_06v0 ad=13p pd=50.52u as=13p ps=50.52u w=50u l=0.7u
X247 a_18245_110628# a_20789_137064# VSS VSS nfet_06v0 ad=1.3p pd=5.52u as=1.3p ps=5.52u w=5u l=0.7u
X248 a_17684_180275# a_17684_180275# VSS VSS nfet_06v0 ad=13p pd=50.52u as=13p ps=50.52u w=50u l=0.7u
X249 VSS a_17684_180275# a_17684_180275# VSS nfet_06v0 ad=13p pd=50.52u as=13p ps=50.52u w=50u l=0.7u
X250 a_17684_180275# a_17684_180275# VSS VSS nfet_06v0 ad=13p pd=50.52u as=13p ps=50.52u w=50u l=0.7u
X251 VSS a_17684_180275# a_17684_180275# VSS nfet_06v0 ad=22p pd=0.10088m as=13p ps=50.52u w=50u l=0.7u
X252 ESD_RAIL ESD_RAIL a_17684_168611# VSS nfet_06v0 ad=13p pd=50.52u as=13p ps=50.52u w=50u l=0.7u
X253 a_18245_110628# a_20789_137064# ESD_RAIL ESD_RAIL pfet_06v0 ad=1.3p pd=5.52u as=1.3p ps=5.52u w=5u l=0.7u
X254 a_17684_180275# a_17684_180275# VSS VSS nfet_06v0 ad=13p pd=50.52u as=13p ps=50.52u w=50u l=0.7u
X255 a_17684_180275# a_17684_180275# VSS VSS nfet_06v0 ad=13p pd=50.52u as=13p ps=50.52u w=50u l=0.7u
X256 VSS a_17684_180275# a_17684_180275# VSS nfet_06v0 ad=13p pd=50.52u as=13p ps=50.52u w=50u l=0.7u
X257 a_17684_180275# a_17684_180275# VSS VSS nfet_06v0 ad=13p pd=50.52u as=13p ps=50.52u w=50u l=0.7u
X258 VSS a_18245_110628# ESD_RAIL VSS nfet_06v0 ad=13p pd=50.52u as=13p ps=50.52u w=50u l=0.7u
X259 ESD_RAIL ESD_RAIL a_17684_168611# VSS nfet_06v0 ad=13p pd=50.52u as=13p ps=50.52u w=50u l=0.7u
X260 a_17684_168611# a_17684_168611# a_17684_180275# VSS nfet_06v0 ad=13p pd=50.52u as=13p ps=50.52u w=50u l=0.7u
X261 a_17684_180275# a_17684_180275# VSS VSS nfet_06v0 ad=13p pd=50.52u as=13p ps=50.52u w=50u l=0.7u
X262 a_17684_180275# a_17684_168611# a_17684_168611# VSS nfet_06v0 ad=13p pd=50.52u as=13p ps=50.52u w=50u l=0.7u
X263 VSS a_18245_110628# ESD_RAIL VSS nfet_06v0 ad=13p pd=50.52u as=13p ps=50.52u w=50u l=0.7u
X264 a_17684_168611# ESD_RAIL ESD_RAIL VSS nfet_06v0 ad=13p pd=50.52u as=13p ps=50.52u w=50u l=0.7u
X265 a_17684_168611# a_17684_168611# a_17684_180275# VSS nfet_06v0 ad=13p pd=50.52u as=13p ps=50.52u w=50u l=0.7u
X266 VSS a_17684_180275# a_17684_180275# VSS nfet_06v0 ad=13p pd=50.52u as=13p ps=50.52u w=50u l=0.7u
X267 a_17684_180275# a_17684_168611# a_17684_168611# VSS nfet_06v0 ad=13p pd=50.52u as=13p ps=50.52u w=50u l=0.7u
X268 a_18245_110628# a_20789_137064# ESD_RAIL ESD_RAIL pfet_06v0 ad=1.3p pd=5.52u as=1.3p ps=5.52u w=5u l=0.7u
X269 a_17684_168611# ESD_RAIL ESD_RAIL VSS nfet_06v0 ad=13p pd=50.52u as=13p ps=50.52u w=50u l=0.7u
X270 a_17684_180275# a_17684_180275# VSS VSS nfet_06v0 ad=13p pd=50.52u as=13p ps=50.52u w=50u l=0.7u
X271 a_17684_168611# ESD_RAIL ESD_RAIL VSS nfet_06v0 ad=13p pd=50.52u as=13p ps=50.52u w=50u l=0.7u
X272 VSS a_17684_180275# a_17684_180275# VSS nfet_06v0 ad=13p pd=50.52u as=13p ps=50.52u w=50u l=0.7u
X273 a_17684_168611# a_17684_168611# a_17684_180275# VSS nfet_06v0 ad=13p pd=50.52u as=13p ps=50.52u w=50u l=0.7u
X274 a_17684_180275# a_17684_180275# VSS VSS nfet_06v0 ad=13p pd=50.52u as=13p ps=50.52u w=50u l=0.7u
X275 a_17005_151545# a_29878_151545# ESD_RAIL ppolyf_u r_width=0.8u r_length=63.855u
X276 a_17684_168611# ESD_RAIL ESD_RAIL VSS nfet_06v0 ad=13p pd=50.52u as=13p ps=50.52u w=50u l=0.7u
X277 a_17684_180275# a_17684_168611# a_17684_168611# VSS nfet_06v0 ad=13p pd=50.52u as=13p ps=50.52u w=50u l=0.7u
X278 VSS a_18245_110628# ESD_RAIL VSS nfet_06v0 ad=13p pd=50.52u as=13p ps=50.52u w=50u l=0.7u
X279 a_17684_168611# a_17684_168611# a_17684_180275# VSS nfet_06v0 ad=13p pd=50.52u as=13p ps=50.52u w=50u l=0.7u
X280 VSS a_18245_110628# ESD_RAIL VSS nfet_06v0 ad=13p pd=50.52u as=13p ps=50.52u w=50u l=0.7u
X281 ESD_RAIL ESD_RAIL a_17684_168611# VSS nfet_06v0 ad=13p pd=50.52u as=13p ps=50.52u w=50u l=0.7u
X282 a_17684_180275# a_17684_180275# VSS VSS nfet_06v0 ad=13p pd=50.52u as=13p ps=50.52u w=50u l=0.7u
X283 ESD_RAIL ESD_RAIL a_17684_168611# VSS nfet_06v0 ad=13p pd=50.52u as=13p ps=50.52u w=50u l=0.7u
X284 VSS a_17684_180275# a_17684_180275# VSS nfet_06v0 ad=13p pd=50.52u as=13p ps=50.52u w=50u l=0.7u
X285 a_17684_180275# a_17684_168611# a_17684_168611# VSS nfet_06v0 ad=13p pd=50.52u as=13p ps=50.52u w=50u l=0.7u
X286 a_17684_180275# a_17684_168611# a_17684_168611# VSS nfet_06v0 ad=13p pd=50.52u as=13p ps=50.52u w=50u l=0.7u
X287 a_17684_168611# ESD_RAIL ESD_RAIL VSS nfet_06v0 ad=22p pd=0.10088m as=13p ps=50.52u w=50u l=0.7u
X288 ESD_RAIL ESD_RAIL a_17684_168611# VSS nfet_06v0 ad=13p pd=50.52u as=13p ps=50.52u w=50u l=0.7u
X289 a_17684_168611# ESD_RAIL ESD_RAIL VSS nfet_06v0 ad=13p pd=50.52u as=13p ps=50.52u w=50u l=0.7u
D5 PAD_N ESD_RAIL diode_pd2nw_06v0 pj=51.8u area=22.5p
X290 a_17684_180275# a_17684_180275# VSS VSS nfet_06v0 ad=13p pd=50.52u as=13p ps=50.52u w=50u l=0.7u
X291 a_17684_168611# a_17684_168611# a_17684_180275# VSS nfet_06v0 ad=13p pd=50.52u as=13p ps=50.52u w=50u l=0.7u
X292 ESD_RAIL ESD_RAIL a_17684_168611# VSS nfet_06v0 ad=13p pd=50.52u as=13p ps=50.52u w=50u l=0.7u
X293 ESD_RAIL ESD_RAIL a_17684_168611# VSS nfet_06v0 ad=13p pd=50.52u as=13p ps=50.52u w=50u l=0.7u
X294 ESD_RAIL a_18245_110628# VSS VSS nfet_06v0 ad=13p pd=50.52u as=13p ps=50.52u w=50u l=0.7u
X295 ESD_RAIL a_18245_110628# VSS VSS nfet_06v0 ad=13p pd=50.52u as=13p ps=50.52u w=50u l=0.7u
D6 PAD_P ESD_RAIL diode_pd2nw_06v0 pj=51.8u area=22.5p
X296 a_17684_168611# ESD_RAIL ESD_RAIL VSS nfet_06v0 ad=13p pd=50.52u as=13p ps=50.52u w=50u l=0.7u
X297 VSS a_17684_180275# a_17684_180275# VSS nfet_06v0 ad=13p pd=50.52u as=13p ps=50.52u w=50u l=0.7u
X298 ESD_RAIL ESD_RAIL a_17684_168611# VSS nfet_06v0 ad=13p pd=50.52u as=13p ps=50.52u w=50u l=0.7u
D7 PAD_N ESD_RAIL diode_pd2nw_06v0 pj=51.8u area=22.5p
X299 a_17684_180275# a_17684_168611# a_17684_168611# VSS nfet_06v0 ad=13p pd=50.52u as=13p ps=50.52u w=50u l=0.7u
X300 ESD_RAIL ESD_RAIL a_17684_168611# VSS nfet_06v0 ad=13p pd=50.52u as=13p ps=50.52u w=50u l=0.7u
X301 a_17684_168611# a_17684_168611# a_17684_180275# VSS nfet_06v0 ad=13p pd=50.52u as=13p ps=50.52u w=50u l=0.7u
X302 a_17684_180275# a_17684_168611# a_17684_168611# VSS nfet_06v0 ad=13p pd=50.52u as=13p ps=50.52u w=50u l=0.7u
X303 a_17684_168611# a_17684_168611# a_17684_180275# VSS nfet_06v0 ad=13p pd=50.52u as=13p ps=50.52u w=50u l=0.7u
X304 VSS a_17684_180275# a_17684_180275# VSS nfet_06v0 ad=13p pd=50.52u as=13p ps=50.52u w=50u l=0.7u
X305 a_17684_180275# a_17684_168611# a_17684_168611# VSS nfet_06v0 ad=13p pd=50.52u as=13p ps=50.52u w=50u l=0.7u
X306 a_17684_168611# ESD_RAIL ESD_RAIL VSS nfet_06v0 ad=13p pd=50.52u as=13p ps=50.52u w=50u l=0.7u
X307 a_17684_180275# a_17684_180275# VSS VSS nfet_06v0 ad=13p pd=50.52u as=13p ps=50.52u w=50u l=0.7u
X308 a_17684_168611# a_17684_168611# a_17684_180275# VSS nfet_06v0 ad=13p pd=50.52u as=13p ps=50.52u w=50u l=0.7u
X309 a_18245_110628# a_20789_137064# ESD_RAIL ESD_RAIL pfet_06v0 ad=1.3p pd=5.52u as=1.3p ps=5.52u w=5u l=0.7u
X310 ESD_RAIL ESD_RAIL a_17684_168611# VSS nfet_06v0 ad=13p pd=50.52u as=13p ps=50.52u w=50u l=0.7u
X311 a_17684_168611# ESD_RAIL ESD_RAIL VSS nfet_06v0 ad=13p pd=50.52u as=13p ps=50.52u w=50u l=0.7u
X312 ESD_RAIL ESD_RAIL a_17684_168611# VSS nfet_06v0 ad=13p pd=50.52u as=13p ps=50.52u w=50u l=0.7u
X313 a_17684_180275# a_17684_168611# a_17684_168611# VSS nfet_06v0 ad=13p pd=50.52u as=13p ps=50.52u w=50u l=0.7u
X314 VSS a_17684_180275# a_17684_180275# VSS nfet_06v0 ad=13p pd=50.52u as=13p ps=50.52u w=50u l=0.7u
X315 a_17684_168611# a_17684_168611# a_17684_180275# VSS nfet_06v0 ad=13p pd=50.52u as=13p ps=50.52u w=50u l=0.7u
X316 a_17684_168611# a_17684_168611# a_17684_180275# VSS nfet_06v0 ad=13p pd=50.52u as=13p ps=50.52u w=50u l=0.7u
X317 a_17005_152385# a_29878_152665# ESD_RAIL ppolyf_u r_width=0.8u r_length=63.855u
X318 ESD_RAIL ESD_RAIL a_17684_168611# VSS nfet_06v0 ad=13p pd=50.52u as=13p ps=50.52u w=50u l=0.7u
X319 a_17684_180275# a_17684_180275# VSS VSS nfet_06v0 ad=13p pd=50.52u as=13p ps=50.52u w=50u l=0.7u
X320 a_17684_180275# a_17684_180275# VSS VSS nfet_06v0 ad=13p pd=50.52u as=13p ps=50.52u w=50u l=0.7u
X321 VSS a_17684_180275# a_17684_180275# VSS nfet_06v0 ad=13p pd=50.52u as=13p ps=50.52u w=50u l=0.7u
X322 a_17684_180275# a_17684_168611# a_17684_168611# VSS nfet_06v0 ad=13p pd=50.52u as=13p ps=50.52u w=50u l=0.7u
X323 a_17684_168611# ESD_RAIL ESD_RAIL VSS nfet_06v0 ad=13p pd=50.52u as=13p ps=50.52u w=50u l=0.7u
X324 a_17684_168611# a_17684_168611# a_17684_180275# VSS nfet_06v0 ad=13p pd=50.52u as=13p ps=50.52u w=50u l=0.7u
X325 a_17684_180275# a_17684_168611# a_17684_168611# VSS nfet_06v0 ad=13p pd=50.52u as=13p ps=50.52u w=50u l=0.7u
X326 a_18245_110628# a_20789_137064# ESD_RAIL ESD_RAIL pfet_06v0 ad=1.3p pd=5.52u as=1.3p ps=5.52u w=5u l=0.7u
X327 a_17684_168611# a_17684_168611# a_17684_180275# VSS nfet_06v0 ad=13p pd=50.52u as=13p ps=50.52u w=50u l=0.7u
X328 VSS a_20789_137064# a_18245_110628# VSS nfet_06v0 ad=2.2p pd=10.88u as=1.3p ps=5.52u w=5u l=0.7u
X329 ESD_RAIL ESD_RAIL a_17684_168611# VSS nfet_06v0 ad=13p pd=50.52u as=13p ps=50.52u w=50u l=0.7u
X330 BIAS_P_1 BIAS_P_2 VSS ppolyf_u_1k r_width=1u r_length=12.5u
X331 a_17684_168611# ESD_RAIL ESD_RAIL VSS nfet_06v0 ad=13p pd=50.52u as=13p ps=50.52u w=50u l=0.7u
X332 a_17684_180275# a_17684_168611# a_17684_168611# VSS nfet_06v0 ad=13p pd=50.52u as=13p ps=50.52u w=50u l=0.7u
X333 a_17684_168611# a_17684_168611# a_17684_180275# VSS nfet_06v0 ad=13p pd=50.52u as=13p ps=50.52u w=50u l=0.7u
X334 VSS a_18245_110628# ESD_RAIL VSS nfet_06v0 ad=13p pd=50.52u as=13p ps=50.52u w=50u l=0.7u
X335 ESD_RAIL a_20789_137064# a_18245_110628# ESD_RAIL pfet_06v0 ad=1.3p pd=5.52u as=1.3p ps=5.52u w=5u l=0.7u
X336 a_17684_180275# a_17684_168611# a_17684_168611# VSS nfet_06v0 ad=13p pd=50.52u as=13p ps=50.52u w=50u l=0.7u
X337 a_17684_180275# a_17684_180275# VSS VSS nfet_06v0 ad=13p pd=50.52u as=13p ps=50.52u w=50u l=0.7u
X338 a_17684_180275# a_17684_168611# a_17684_168611# VSS nfet_06v0 ad=13p pd=50.52u as=13p ps=50.52u w=50u l=0.7u
X339 VSS a_18245_110628# ESD_RAIL VSS nfet_06v0 ad=13p pd=50.52u as=13p ps=50.52u w=50u l=0.7u
X340 VSS a_17684_180275# a_17684_180275# VSS nfet_06v0 ad=13p pd=50.52u as=13p ps=50.52u w=50u l=0.7u
X341 a_17684_168611# a_17684_168611# a_17684_180275# VSS nfet_06v0 ad=13p pd=50.52u as=13p ps=50.52u w=50u l=0.7u
X342 a_17684_180275# a_17684_168611# a_17684_168611# VSS nfet_06v0 ad=13p pd=50.52u as=13p ps=50.52u w=50u l=0.7u
X343 BIAS_N_0 BIAS_N_1 VSS ppolyf_u_1k r_width=1u r_length=12.5u
X344 VSS a_18245_110628# ESD_RAIL VSS nfet_06v0 ad=13p pd=50.52u as=13p ps=50.52u w=50u l=0.7u
X345 a_17684_180275# a_17684_168611# a_17684_168611# VSS nfet_06v0 ad=13p pd=50.52u as=13p ps=50.52u w=50u l=0.7u
X346 a_17684_180275# a_17684_168611# a_17684_168611# VSS nfet_06v0 ad=13p pd=50.52u as=13p ps=50.52u w=50u l=0.7u
X347 a_17684_168611# ESD_RAIL ESD_RAIL VSS nfet_06v0 ad=13p pd=50.52u as=13p ps=50.52u w=50u l=0.7u
X348 a_17684_168611# a_17684_168611# a_17684_180275# VSS nfet_06v0 ad=13p pd=50.52u as=13p ps=50.52u w=50u l=0.7u
X349 a_17684_180275# a_17684_168611# a_17684_168611# VSS nfet_06v0 ad=13p pd=50.52u as=13p ps=50.52u w=50u l=0.7u
X350 ESD_RAIL ESD_RAIL a_17684_168611# VSS nfet_06v0 ad=13p pd=50.52u as=13p ps=50.52u w=50u l=0.7u
X351 a_17684_180275# a_17684_168611# a_17684_168611# VSS nfet_06v0 ad=13p pd=50.52u as=13p ps=50.52u w=50u l=0.7u
X352 ESD_RAIL a_20789_137064# a_18245_110628# ESD_RAIL pfet_06v0 ad=1.3p pd=5.52u as=1.3p ps=5.52u w=5u l=0.7u
X353 a_18245_110628# a_20789_137064# VSS VSS nfet_06v0 ad=1.3p pd=5.52u as=1.3p ps=5.52u w=5u l=0.7u
X354 a_17684_180275# a_17684_180275# VSS VSS nfet_06v0 ad=13p pd=50.52u as=13p ps=50.52u w=50u l=0.7u
X355 a_17684_180275# a_17684_168611# a_17684_168611# VSS nfet_06v0 ad=13p pd=50.52u as=13p ps=50.52u w=50u l=0.7u
X356 a_17684_168611# a_17684_168611# a_17684_180275# VSS nfet_06v0 ad=13p pd=50.52u as=13p ps=50.52u w=50u l=0.7u
X357 a_18245_110628# a_20789_137064# ESD_RAIL ESD_RAIL pfet_06v0 ad=1.3p pd=5.52u as=2.2p ps=10.88u w=5u l=0.7u
X358 a_17684_168611# a_17684_168611# a_17684_180275# VSS nfet_06v0 ad=13p pd=50.52u as=13p ps=50.52u w=50u l=0.7u
X359 a_19813_137064# a_17005_151545# VSS VSS nfet_06v0 ad=2.2p pd=10.88u as=2.2p ps=10.88u w=5u l=0.7u
X360 a_17684_168611# ESD_RAIL ESD_RAIL VSS nfet_06v0 ad=13p pd=50.52u as=13p ps=50.52u w=50u l=0.7u
X361 VSS a_17684_180275# a_17684_180275# VSS nfet_06v0 ad=13p pd=50.52u as=13p ps=50.52u w=50u l=0.7u
X362 a_17684_180275# a_17684_168611# a_17684_168611# VSS nfet_06v0 ad=13p pd=50.52u as=13p ps=50.52u w=50u l=0.7u
X363 ESD_RAIL ESD_RAIL a_17684_168611# VSS nfet_06v0 ad=13p pd=50.52u as=13p ps=50.52u w=50u l=0.7u
X364 a_17684_180275# a_17684_180275# VSS VSS nfet_06v0 ad=13p pd=50.52u as=13p ps=50.52u w=50u l=0.7u
X365 a_17684_180275# a_17684_168611# a_17684_168611# VSS nfet_06v0 ad=13p pd=50.52u as=13p ps=50.52u w=50u l=0.7u
X366 a_17005_153505# a_29878_153785# ESD_RAIL ppolyf_u r_width=0.8u r_length=63.855u
X367 ESD_RAIL ESD_RAIL a_17684_168611# VSS nfet_06v0 ad=13p pd=50.52u as=13p ps=50.52u w=50u l=0.7u
X368 a_17684_168611# a_17684_168611# a_17684_180275# VSS nfet_06v0 ad=13p pd=50.52u as=13p ps=50.52u w=50u l=0.7u
X369 a_17684_168611# ESD_RAIL ESD_RAIL VSS nfet_06v0 ad=13p pd=50.52u as=13p ps=50.52u w=50u l=0.7u
X370 VSS a_17684_180275# a_17684_180275# VSS nfet_06v0 ad=13p pd=50.52u as=13p ps=50.52u w=50u l=0.7u
X371 VSS a_17684_180275# a_17684_180275# VSS nfet_06v0 ad=13p pd=50.52u as=13p ps=50.52u w=50u l=0.7u
X372 ESD_RAIL a_18245_110628# VSS VSS nfet_06v0 ad=13p pd=50.52u as=13p ps=50.52u w=50u l=0.7u
X373 a_18245_110628# a_20789_137064# VSS VSS nfet_06v0 ad=1.3p pd=5.52u as=1.3p ps=5.52u w=5u l=0.7u
X374 VSS a_17684_180275# a_17684_180275# VSS nfet_06v0 ad=13p pd=50.52u as=13p ps=50.52u w=50u l=0.7u
X375 a_17684_180275# a_17684_168611# a_17684_168611# VSS nfet_06v0 ad=13p pd=50.52u as=13p ps=50.52u w=50u l=0.7u
X376 a_18245_110628# a_20789_137064# ESD_RAIL ESD_RAIL pfet_06v0 ad=1.3p pd=5.52u as=1.3p ps=5.52u w=5u l=0.7u
X377 ESD_RAIL ESD_RAIL a_17684_168611# VSS nfet_06v0 ad=13p pd=50.52u as=13p ps=50.52u w=50u l=0.7u
X378 ESD_RAIL a_18245_110628# VSS VSS nfet_06v0 ad=13p pd=50.52u as=13p ps=50.52u w=50u l=0.7u
X379 VSS a_19813_137064# a_20789_137064# VSS nfet_06v0 ad=1.3p pd=5.52u as=1.3p ps=5.52u w=5u l=0.7u
X380 a_17684_168611# a_17684_168611# a_17684_180275# VSS nfet_06v0 ad=13p pd=50.52u as=13p ps=50.52u w=50u l=0.7u
X381 ESD_RAIL a_18245_110628# VSS VSS nfet_06v0 ad=13p pd=50.52u as=13p ps=50.52u w=50u l=0.7u
X382 a_17684_168611# ESD_RAIL ESD_RAIL VSS nfet_06v0 ad=13p pd=50.52u as=13p ps=50.52u w=50u l=0.7u
X383 a_17684_180275# a_17684_168611# a_17684_168611# VSS nfet_06v0 ad=13p pd=50.52u as=13p ps=50.52u w=50u l=0.7u
X384 a_17684_180275# a_17684_180275# VSS VSS nfet_06v0 ad=13p pd=50.52u as=13p ps=50.52u w=50u l=0.7u
X385 VSS a_17684_180275# a_17684_180275# VSS nfet_06v0 ad=13p pd=50.52u as=13p ps=50.52u w=50u l=0.7u
X386 VSS a_17684_180275# a_17684_180275# VSS nfet_06v0 ad=13p pd=50.52u as=13p ps=50.52u w=50u l=0.7u
X387 a_17684_168611# a_17684_168611# a_17684_180275# VSS nfet_06v0 ad=13p pd=50.52u as=13p ps=50.52u w=50u l=0.7u
X388 a_17684_180275# a_17684_180275# VSS VSS nfet_06v0 ad=13p pd=50.52u as=13p ps=50.52u w=50u l=0.7u
X389 VSS a_17684_180275# a_17684_180275# VSS nfet_06v0 ad=13p pd=50.52u as=13p ps=50.52u w=50u l=0.7u
X390 a_17684_180275# a_17684_180275# VSS VSS nfet_06v0 ad=13p pd=50.52u as=13p ps=50.52u w=50u l=0.7u
X391 VSS a_19813_137064# a_20789_137064# VSS nfet_06v0 ad=1.3p pd=5.52u as=1.3p ps=5.52u w=5u l=0.7u
X392 ESD_RAIL ESD_RAIL a_17684_168611# VSS nfet_06v0 ad=13p pd=50.52u as=13p ps=50.52u w=50u l=0.7u
X393 a_17684_180275# a_17684_180275# VSS VSS nfet_06v0 ad=13p pd=50.52u as=13p ps=50.52u w=50u l=0.7u
X394 a_17684_168611# a_17684_168611# a_17684_180275# VSS nfet_06v0 ad=13p pd=50.52u as=13p ps=50.52u w=50u l=0.7u
X395 a_17684_168611# ESD_RAIL ESD_RAIL VSS nfet_06v0 ad=13p pd=50.52u as=13p ps=50.52u w=50u l=0.7u
X396 a_17684_180275# a_17684_168611# a_17684_168611# VSS nfet_06v0 ad=13p pd=50.52u as=13p ps=50.52u w=50u l=0.7u
X397 ESD_RAIL ESD_RAIL a_17684_168611# VSS nfet_06v0 ad=13p pd=50.52u as=13p ps=50.52u w=50u l=0.7u
X398 a_17684_168611# a_17684_168611# a_17684_180275# VSS nfet_06v0 ad=13p pd=50.52u as=13p ps=50.52u w=50u l=0.7u
X399 a_17684_180275# a_17684_180275# VSS VSS nfet_06v0 ad=13p pd=50.52u as=13p ps=50.52u w=50u l=0.7u
X400 a_17684_168611# ESD_RAIL ESD_RAIL VSS nfet_06v0 ad=13p pd=50.52u as=13p ps=50.52u w=50u l=0.7u
X401 a_17684_168611# ESD_RAIL ESD_RAIL VSS nfet_06v0 ad=13p pd=50.52u as=13p ps=50.52u w=50u l=0.7u
X402 VSS a_17684_180275# a_17684_180275# VSS nfet_06v0 ad=13p pd=50.52u as=13p ps=50.52u w=50u l=0.7u
X403 a_17684_168611# a_17684_168611# a_17684_180275# VSS nfet_06v0 ad=13p pd=50.52u as=13p ps=50.52u w=50u l=0.7u
D8 VSS ESD_RAIL diode_nd2ps_06v0 pj=82u area=40p
X404 a_17684_180275# a_17684_180275# VSS VSS nfet_06v0 ad=13p pd=50.52u as=13p ps=50.52u w=50u l=0.7u
X405 VSS a_17684_180275# a_17684_180275# VSS nfet_06v0 ad=13p pd=50.52u as=13p ps=50.52u w=50u l=0.7u
X406 a_17684_168611# ESD_RAIL ESD_RAIL VSS nfet_06v0 ad=13p pd=50.52u as=13p ps=50.52u w=50u l=0.7u
X407 VSS a_18245_110628# ESD_RAIL VSS nfet_06v0 ad=13p pd=50.52u as=13p ps=50.52u w=50u l=0.7u
X408 VSS a_18245_110628# ESD_RAIL VSS nfet_06v0 ad=13p pd=50.52u as=13p ps=50.52u w=50u l=0.7u
X409 BIAS_P_6 VCM VSS ppolyf_u_1k r_width=1u r_length=12.5u
X410 VSS a_18245_110628# ESD_RAIL VSS nfet_06v0 ad=13p pd=50.52u as=13p ps=50.52u w=50u l=0.7u
X411 VSS a_18245_110628# ESD_RAIL VSS nfet_06v0 ad=13p pd=50.52u as=13p ps=50.52u w=50u l=0.7u
X412 VSS a_17684_180275# a_17684_180275# VSS nfet_06v0 ad=13p pd=50.52u as=13p ps=50.52u w=50u l=0.7u
X413 a_17684_168611# ESD_RAIL ESD_RAIL VSS nfet_06v0 ad=13p pd=50.52u as=13p ps=50.52u w=50u l=0.7u
X414 ESD_RAIL ESD_RAIL a_17684_168611# VSS nfet_06v0 ad=13p pd=50.52u as=13p ps=50.52u w=50u l=0.7u
X415 a_17684_168611# a_17684_168611# a_17684_180275# VSS nfet_06v0 ad=13p pd=50.52u as=13p ps=50.52u w=50u l=0.7u
X416 VSS a_18245_110628# ESD_RAIL VSS nfet_06v0 ad=13p pd=50.52u as=13p ps=50.52u w=50u l=0.7u
X417 a_17684_168611# ESD_RAIL ESD_RAIL VSS nfet_06v0 ad=13p pd=50.52u as=13p ps=50.52u w=50u l=0.7u
X418 VSS a_18245_110628# ESD_RAIL VSS nfet_06v0 ad=13p pd=50.52u as=13p ps=50.52u w=50u l=0.7u
X419 a_17684_180275# a_17684_168611# a_17684_168611# VSS nfet_06v0 ad=13p pd=50.52u as=13p ps=50.52u w=50u l=0.7u
X420 ESD_RAIL ESD_RAIL a_17684_168611# VSS nfet_06v0 ad=13p pd=50.52u as=13p ps=50.52u w=50u l=0.7u
X421 VSS a_17684_180275# a_17684_180275# VSS nfet_06v0 ad=13p pd=50.52u as=13p ps=50.52u w=50u l=0.7u
X422 a_17684_168611# ESD_RAIL ESD_RAIL VSS nfet_06v0 ad=13p pd=50.52u as=13p ps=50.52u w=50u l=0.7u
X423 ESD_RAIL ESD_RAIL a_17684_168611# VSS nfet_06v0 ad=13p pd=50.52u as=13p ps=50.52u w=50u l=0.7u
X424 a_17684_180275# a_17684_180275# VSS VSS nfet_06v0 ad=13p pd=50.52u as=13p ps=50.52u w=50u l=0.7u
X425 ESD_RAIL a_18245_110628# VSS VSS nfet_06v0 ad=22p pd=0.10088m as=13p ps=50.52u w=50u l=0.7u
X426 a_17005_153505# a_29878_153225# ESD_RAIL ppolyf_u r_width=0.8u r_length=63.855u
X427 a_17684_180275# a_17684_180275# VSS VSS nfet_06v0 ad=13p pd=50.52u as=13p ps=50.52u w=50u l=0.7u
X428 a_17684_180275# a_17684_180275# VSS VSS nfet_06v0 ad=13p pd=50.52u as=13p ps=50.52u w=50u l=0.7u
X429 ESD_RAIL ESD_RAIL a_17684_168611# VSS nfet_06v0 ad=13p pd=50.52u as=13p ps=50.52u w=50u l=0.7u
X430 a_17684_180275# a_17684_168611# a_17684_168611# VSS nfet_06v0 ad=13p pd=50.52u as=13p ps=50.52u w=50u l=0.7u
X431 a_17684_180275# a_17684_168611# a_17684_168611# VSS nfet_06v0 ad=13p pd=50.52u as=13p ps=50.52u w=50u l=0.7u
X432 a_17684_180275# a_17684_180275# VSS VSS nfet_06v0 ad=13p pd=50.52u as=13p ps=50.52u w=50u l=0.7u
X433 ESD_RAIL ESD_RAIL a_17684_168611# VSS nfet_06v0 ad=13p pd=50.52u as=13p ps=50.52u w=50u l=0.7u
X434 a_17684_168611# ESD_RAIL ESD_RAIL VSS nfet_06v0 ad=13p pd=50.52u as=13p ps=50.52u w=50u l=0.7u
X435 ESD_RAIL ESD_RAIL a_17684_168611# VSS nfet_06v0 ad=13p pd=50.52u as=13p ps=50.52u w=50u l=0.7u
X436 a_17684_168611# ESD_RAIL ESD_RAIL VSS nfet_06v0 ad=13p pd=50.52u as=13p ps=50.52u w=50u l=0.7u
X437 VSS a_17684_180275# a_17684_180275# VSS nfet_06v0 ad=13p pd=50.52u as=13p ps=50.52u w=50u l=0.7u
D9 PAD_P ESD_RAIL diode_pd2nw_06v0 pj=51.8u area=22.5p
X438 a_17684_168611# a_17684_168611# a_17684_180275# VSS nfet_06v0 ad=13p pd=50.52u as=13p ps=50.52u w=50u l=0.7u
X439 a_17684_168611# a_17684_168611# a_17684_180275# VSS nfet_06v0 ad=13p pd=50.52u as=13p ps=50.52u w=50u l=0.7u
X440 VSS a_17684_180275# a_17684_180275# VSS nfet_06v0 ad=13p pd=50.52u as=13p ps=50.52u w=50u l=0.7u
X441 VSS a_17684_180275# a_17684_180275# VSS nfet_06v0 ad=13p pd=50.52u as=13p ps=50.52u w=50u l=0.7u
X442 a_17684_168611# ESD_RAIL ESD_RAIL VSS nfet_06v0 ad=13p pd=50.52u as=13p ps=50.52u w=50u l=0.7u
X443 a_17684_180275# a_17684_168611# a_17684_168611# VSS nfet_06v0 ad=13p pd=50.52u as=13p ps=50.52u w=50u l=0.7u
X444 a_17684_168611# a_17684_168611# a_17684_180275# VSS nfet_06v0 ad=13p pd=50.52u as=13p ps=50.52u w=50u l=0.7u
X445 a_17684_180275# a_17684_168611# a_17684_168611# VSS nfet_06v0 ad=13p pd=50.52u as=13p ps=50.52u w=50u l=0.7u
X446 ESD_RAIL ESD_RAIL a_17684_168611# VSS nfet_06v0 ad=13p pd=50.52u as=13p ps=50.52u w=50u l=0.7u
X447 a_17684_168611# ESD_RAIL ESD_RAIL VSS nfet_06v0 ad=13p pd=50.52u as=13p ps=50.52u w=50u l=0.7u
X448 a_17684_180275# a_17684_168611# a_17684_168611# VSS nfet_06v0 ad=13p pd=50.52u as=13p ps=50.52u w=50u l=0.7u
X449 a_17684_180275# a_17684_168611# a_17684_168611# VSS nfet_06v0 ad=13p pd=50.52u as=13p ps=50.52u w=50u l=0.7u
X450 a_17684_168611# a_17684_168611# a_17684_180275# VSS nfet_06v0 ad=13p pd=50.52u as=13p ps=50.52u w=50u l=0.7u
X451 ESD_RAIL a_18245_110628# VSS VSS nfet_06v0 ad=13p pd=50.52u as=13p ps=50.52u w=50u l=0.7u
X452 ESD_RAIL ESD_RAIL a_17684_168611# VSS nfet_06v0 ad=13p pd=50.52u as=13p ps=50.52u w=50u l=0.7u
X453 ESD_RAIL ESD_RAIL a_17684_168611# VSS nfet_06v0 ad=13p pd=50.52u as=13p ps=50.52u w=50u l=0.7u
X454 a_17684_180275# a_17684_168611# a_17684_168611# VSS nfet_06v0 ad=13p pd=50.52u as=13p ps=50.52u w=50u l=0.7u
X455 ESD_RAIL a_29878_154345# ESD_RAIL ppolyf_u r_width=0.8u r_length=63.855u
X456 a_17684_180275# a_17684_168611# a_17684_168611# VSS nfet_06v0 ad=13p pd=50.52u as=13p ps=50.52u w=50u l=0.7u
X457 a_17684_168611# a_17684_168611# a_17684_180275# VSS nfet_06v0 ad=13p pd=50.52u as=13p ps=50.52u w=50u l=0.7u
X458 a_17684_180275# a_17684_168611# a_17684_168611# VSS nfet_06v0 ad=13p pd=50.52u as=13p ps=50.52u w=50u l=0.7u
X459 ESD_RAIL ESD_RAIL a_17684_168611# VSS nfet_06v0 ad=13p pd=50.52u as=13p ps=50.52u w=50u l=0.7u
X460 a_17684_168611# a_17684_168611# a_17684_180275# VSS nfet_06v0 ad=13p pd=50.52u as=13p ps=50.52u w=50u l=0.7u
X461 a_17684_180275# a_17684_168611# a_17684_168611# VSS nfet_06v0 ad=13p pd=50.52u as=13p ps=50.52u w=50u l=0.7u
X462 a_17684_168611# a_17684_168611# a_17684_180275# VSS nfet_06v0 ad=13p pd=50.52u as=13p ps=50.52u w=50u l=0.7u
X463 a_17684_180275# a_17684_168611# a_17684_168611# VSS nfet_06v0 ad=13p pd=50.52u as=13p ps=50.52u w=50u l=0.7u
X464 a_17684_168611# a_17684_168611# a_17684_180275# VSS nfet_06v0 ad=13p pd=50.52u as=13p ps=50.52u w=50u l=0.7u
X465 a_17684_180275# a_17684_168611# a_17684_168611# VSS nfet_06v0 ad=13p pd=50.52u as=13p ps=50.52u w=50u l=0.7u
X466 a_18245_110628# VSS VSS ppolyf_u_1k_6p0 r_width=1u r_length=99.24u
X467 VSS a_17684_180275# a_17684_180275# VSS nfet_06v0 ad=13p pd=50.52u as=13p ps=50.52u w=50u l=0.7u
X468 a_17684_168611# a_17684_168611# a_17684_180275# VSS nfet_06v0 ad=13p pd=50.52u as=22p ps=0.10088m w=50u l=0.7u
X469 a_17684_168611# ESD_RAIL ESD_RAIL VSS nfet_06v0 ad=13p pd=50.52u as=13p ps=50.52u w=50u l=0.7u
X470 a_17684_168611# a_17684_168611# a_17684_180275# VSS nfet_06v0 ad=13p pd=50.52u as=13p ps=50.52u w=50u l=0.7u
X471 a_17684_180275# a_17684_168611# a_17684_168611# VSS nfet_06v0 ad=13p pd=50.52u as=13p ps=50.52u w=50u l=0.7u
X472 VSS a_17684_180275# a_17684_180275# VSS nfet_06v0 ad=13p pd=50.52u as=13p ps=50.52u w=50u l=0.7u
X473 a_17684_168611# ESD_RAIL ESD_RAIL VSS nfet_06v0 ad=13p pd=50.52u as=13p ps=50.52u w=50u l=0.7u
X474 a_17684_168611# ESD_RAIL ESD_RAIL VSS nfet_06v0 ad=13p pd=50.52u as=13p ps=50.52u w=50u l=0.7u
X475 a_17684_168611# a_17684_168611# a_17684_180275# VSS nfet_06v0 ad=13p pd=50.52u as=13p ps=50.52u w=50u l=0.7u
X476 VSS a_18245_110628# ESD_RAIL VSS nfet_06v0 ad=13p pd=50.52u as=13p ps=50.52u w=50u l=0.7u
X477 a_17684_180275# a_17684_168611# a_17684_168611# VSS nfet_06v0 ad=13p pd=50.52u as=13p ps=50.52u w=50u l=0.7u
X478 VSS a_18245_110628# ESD_RAIL VSS nfet_06v0 ad=13p pd=50.52u as=22p ps=0.10088m w=50u l=0.7u
X479 a_17684_168611# a_17684_168611# a_17684_180275# VSS nfet_06v0 ad=13p pd=50.52u as=13p ps=50.52u w=50u l=0.7u
X480 a_17684_180275# a_17684_168611# a_17684_168611# VSS nfet_06v0 ad=13p pd=50.52u as=13p ps=50.52u w=50u l=0.7u
X481 a_17684_180275# a_17684_168611# a_17684_168611# VSS nfet_06v0 ad=13p pd=50.52u as=13p ps=50.52u w=50u l=0.7u
X482 VSS a_18245_110628# ESD_RAIL VSS nfet_06v0 ad=13p pd=50.52u as=13p ps=50.52u w=50u l=0.7u
X483 VSS a_17684_180275# a_17684_180275# VSS nfet_06v0 ad=13p pd=50.52u as=13p ps=50.52u w=50u l=0.7u
X484 a_17684_168611# a_17684_168611# a_17684_180275# VSS nfet_06v0 ad=13p pd=50.52u as=13p ps=50.52u w=50u l=0.7u
X485 a_17684_168611# a_17684_168611# a_17684_180275# VSS nfet_06v0 ad=13p pd=50.52u as=13p ps=50.52u w=50u l=0.7u
X486 ESD_RAIL a_18245_110628# VSS VSS nfet_06v0 ad=22p pd=0.10088m as=13p ps=50.52u w=50u l=0.7u
X487 a_17684_180275# a_17684_180275# VSS VSS nfet_06v0 ad=13p pd=50.52u as=13p ps=50.52u w=50u l=0.7u
X488 ESD_RAIL a_18245_110628# VSS VSS nfet_06v0 ad=13p pd=50.52u as=13p ps=50.52u w=50u l=0.7u
X489 a_17684_180275# a_17684_180275# VSS VSS nfet_06v0 ad=13p pd=50.52u as=13p ps=50.52u w=50u l=0.7u
X490 a_17684_180275# a_17684_168611# a_17684_168611# VSS nfet_06v0 ad=13p pd=50.52u as=13p ps=50.52u w=50u l=0.7u
X491 a_17005_151545# VSS cap_mim_2f0_m4m5_noshield c_width=31.6u c_length=31.6u
X492 VSS a_17684_180275# a_17684_180275# VSS nfet_06v0 ad=13p pd=50.52u as=13p ps=50.52u w=50u l=0.7u
X493 a_17684_168611# a_17684_168611# a_17684_180275# VSS nfet_06v0 ad=13p pd=50.52u as=13p ps=50.52u w=50u l=0.7u
X494 a_17684_180275# a_17684_180275# VSS VSS nfet_06v0 ad=13p pd=50.52u as=13p ps=50.52u w=50u l=0.7u
X495 a_17684_168611# a_17684_168611# a_17684_180275# VSS nfet_06v0 ad=13p pd=50.52u as=13p ps=50.52u w=50u l=0.7u
X496 a_17684_180275# a_17684_180275# VSS VSS nfet_06v0 ad=13p pd=50.52u as=13p ps=50.52u w=50u l=0.7u
X497 a_17684_180275# a_17684_168611# a_17684_168611# VSS nfet_06v0 ad=13p pd=50.52u as=13p ps=50.52u w=50u l=0.7u
X498 VSS a_17684_180275# a_17684_180275# VSS nfet_06v0 ad=13p pd=50.52u as=13p ps=50.52u w=50u l=0.7u
X499 a_17684_180275# a_17684_168611# a_17684_168611# VSS nfet_06v0 ad=13p pd=50.52u as=13p ps=50.52u w=50u l=0.7u
X500 a_17684_168611# a_17684_168611# a_17684_180275# VSS nfet_06v0 ad=13p pd=50.52u as=13p ps=50.52u w=50u l=0.7u
X501 a_20789_137064# a_19813_137064# VSS VSS nfet_06v0 ad=1.3p pd=5.52u as=2.2p ps=10.88u w=5u l=0.7u
X502 a_17684_168611# ESD_RAIL ESD_RAIL VSS nfet_06v0 ad=13p pd=50.52u as=13p ps=50.52u w=50u l=0.7u
X503 a_17684_168611# a_17684_168611# a_17684_180275# VSS nfet_06v0 ad=13p pd=50.52u as=13p ps=50.52u w=50u l=0.7u
X504 a_17684_180275# a_17684_180275# VSS VSS nfet_06v0 ad=13p pd=50.52u as=13p ps=50.52u w=50u l=0.7u
X505 a_17684_180275# a_17684_168611# a_17684_168611# VSS nfet_06v0 ad=13p pd=50.52u as=13p ps=50.52u w=50u l=0.7u
X506 VSS a_17684_180275# a_17684_180275# VSS nfet_06v0 ad=13p pd=50.52u as=13p ps=50.52u w=50u l=0.7u
X507 a_17684_168611# ESD_RAIL ESD_RAIL VSS nfet_06v0 ad=13p pd=50.52u as=13p ps=50.52u w=50u l=0.7u
X508 a_17684_180275# a_17684_180275# VSS VSS nfet_06v0 ad=13p pd=50.52u as=13p ps=50.52u w=50u l=0.7u
X509 VSS a_17684_180275# a_17684_180275# VSS nfet_06v0 ad=13p pd=50.52u as=13p ps=50.52u w=50u l=0.7u
X510 VSS a_17684_180275# a_17684_180275# VSS nfet_06v0 ad=13p pd=50.52u as=13p ps=50.52u w=50u l=0.7u
X511 a_17684_180275# a_17684_180275# VSS VSS nfet_06v0 ad=13p pd=50.52u as=13p ps=50.52u w=50u l=0.7u
X512 ESD_RAIL a_18245_110628# VSS VSS nfet_06v0 ad=13p pd=50.52u as=13p ps=50.52u w=50u l=0.7u
X513 a_17684_180275# a_17684_168611# a_17684_168611# VSS nfet_06v0 ad=13p pd=50.52u as=13p ps=50.52u w=50u l=0.7u
X514 a_17684_180275# a_17684_168611# a_17684_168611# VSS nfet_06v0 ad=13p pd=50.52u as=13p ps=50.52u w=50u l=0.7u
X515 VSS a_17684_180275# a_17684_180275# VSS nfet_06v0 ad=13p pd=50.52u as=13p ps=50.52u w=50u l=0.7u
X516 a_17684_168611# a_17684_168611# a_17684_180275# VSS nfet_06v0 ad=13p pd=50.52u as=13p ps=50.52u w=50u l=0.7u
X517 a_17684_168611# a_17684_168611# a_17684_180275# VSS nfet_06v0 ad=13p pd=50.52u as=13p ps=50.52u w=50u l=0.7u
X518 a_17684_168611# ESD_RAIL ESD_RAIL VSS nfet_06v0 ad=13p pd=50.52u as=13p ps=50.52u w=50u l=0.7u
X519 a_17684_180275# a_17684_180275# VSS VSS nfet_06v0 ad=13p pd=50.52u as=13p ps=50.52u w=50u l=0.7u
X520 ESD_RAIL ESD_RAIL a_17684_168611# VSS nfet_06v0 ad=13p pd=50.52u as=13p ps=50.52u w=50u l=0.7u
X521 ESD_RAIL ESD_RAIL a_17684_168611# VSS nfet_06v0 ad=13p pd=50.52u as=13p ps=50.52u w=50u l=0.7u
X522 a_17684_180275# a_17684_168611# a_17684_168611# VSS nfet_06v0 ad=13p pd=50.52u as=13p ps=50.52u w=50u l=0.7u
X523 a_17684_168611# ESD_RAIL ESD_RAIL VSS nfet_06v0 ad=13p pd=50.52u as=13p ps=50.52u w=50u l=0.7u
X524 VSS a_17684_180275# a_17684_180275# VSS nfet_06v0 ad=13p pd=50.52u as=13p ps=50.52u w=50u l=0.7u
X525 VSS a_18245_110628# ESD_RAIL VSS nfet_06v0 ad=13p pd=50.52u as=13p ps=50.52u w=50u l=0.7u
X526 a_17684_180275# a_17684_180275# VSS VSS nfet_06v0 ad=13p pd=50.52u as=13p ps=50.52u w=50u l=0.7u
X527 ESD_RAIL ESD_RAIL a_17684_168611# VSS nfet_06v0 ad=13p pd=50.52u as=13p ps=50.52u w=50u l=0.7u
X528 VSS a_17684_180275# a_17684_180275# VSS nfet_06v0 ad=13p pd=50.52u as=13p ps=50.52u w=50u l=0.7u
X529 a_17684_180275# a_17684_180275# VSS VSS nfet_06v0 ad=13p pd=50.52u as=13p ps=50.52u w=50u l=0.7u
X530 ESD_RAIL ESD_RAIL a_17684_168611# VSS nfet_06v0 ad=13p pd=50.52u as=13p ps=50.52u w=50u l=0.7u
X531 VSS a_17684_180275# a_17684_180275# VSS nfet_06v0 ad=13p pd=50.52u as=13p ps=50.52u w=50u l=0.7u
D10 VSS PAD_P diode_nd2ps_06v0 pj=51.8u area=22.5p
X532 a_17684_168611# ESD_RAIL ESD_RAIL VSS nfet_06v0 ad=13p pd=50.52u as=13p ps=50.52u w=50u l=0.7u
D11 VSS PAD_N diode_nd2ps_06v0 pj=51.8u area=22.5p
X533 BIAS_N_4 BIAS_N_5 VSS ppolyf_u_1k r_width=1u r_length=12.5u
X534 a_17684_180275# a_17684_180275# VSS VSS nfet_06v0 ad=13p pd=50.52u as=13p ps=50.52u w=50u l=0.7u
D12 VSS PAD_P diode_nd2ps_06v0 pj=51.8u area=22.5p
X535 ESD_RAIL ESD_RAIL a_17684_168611# VSS nfet_06v0 ad=13p pd=50.52u as=13p ps=50.52u w=50u l=0.7u
X536 VSS a_17684_180275# a_17684_180275# VSS nfet_06v0 ad=13p pd=50.52u as=13p ps=50.52u w=50u l=0.7u
X537 a_17684_168611# ESD_RAIL ESD_RAIL VSS nfet_06v0 ad=13p pd=50.52u as=13p ps=50.52u w=50u l=0.7u
X538 a_18245_110628# a_20789_137064# ESD_RAIL ESD_RAIL pfet_06v0 ad=1.3p pd=5.52u as=1.3p ps=5.52u w=5u l=0.7u
X539 ESD_RAIL ESD_RAIL a_17684_168611# VSS nfet_06v0 ad=13p pd=50.52u as=13p ps=50.52u w=50u l=0.7u
X540 a_17684_180275# a_17684_180275# VSS VSS nfet_06v0 ad=13p pd=50.52u as=13p ps=50.52u w=50u l=0.7u
X541 VSS a_17684_180275# a_17684_180275# VSS nfet_06v0 ad=13p pd=50.52u as=13p ps=50.52u w=50u l=0.7u
X542 a_17684_168611# ESD_RAIL ESD_RAIL VSS nfet_06v0 ad=13p pd=50.52u as=13p ps=50.52u w=50u l=0.7u
X543 VSS a_17684_180275# a_17684_180275# VSS nfet_06v0 ad=13p pd=50.52u as=13p ps=50.52u w=50u l=0.7u
X544 a_17684_168611# ESD_RAIL ESD_RAIL VSS nfet_06v0 ad=13p pd=50.52u as=13p ps=50.52u w=50u l=0.7u
X545 ESD_RAIL ESD_RAIL a_17684_168611# VSS nfet_06v0 ad=13p pd=50.52u as=13p ps=50.52u w=50u l=0.7u
X546 VSS a_17684_180275# a_17684_180275# VSS nfet_06v0 ad=13p pd=50.52u as=13p ps=50.52u w=50u l=0.7u
X547 VSS a_18245_110628# ESD_RAIL VSS nfet_06v0 ad=13p pd=50.52u as=13p ps=50.52u w=50u l=0.7u
X548 a_17684_180275# a_17684_180275# VSS VSS nfet_06v0 ad=13p pd=50.52u as=13p ps=50.52u w=50u l=0.7u
X549 VSS a_17684_180275# a_17684_180275# VSS nfet_06v0 ad=13p pd=50.52u as=13p ps=50.52u w=50u l=0.7u
X550 a_17684_180275# a_17684_180275# VSS VSS nfet_06v0 ad=13p pd=50.52u as=13p ps=50.52u w=50u l=0.7u
X551 a_17684_168611# ESD_RAIL ESD_RAIL VSS nfet_06v0 ad=13p pd=50.52u as=13p ps=50.52u w=50u l=0.7u
X552 ESD_RAIL ESD_RAIL a_17684_168611# VSS nfet_06v0 ad=13p pd=50.52u as=13p ps=50.52u w=50u l=0.7u
X553 a_17684_168611# ESD_RAIL ESD_RAIL VSS nfet_06v0 ad=13p pd=50.52u as=13p ps=50.52u w=50u l=0.7u
X554 VSS a_17684_180275# a_17684_180275# VSS nfet_06v0 ad=13p pd=50.52u as=13p ps=50.52u w=50u l=0.7u
X555 ESD_RAIL a_18245_110628# VSS VSS nfet_06v0 ad=13p pd=50.52u as=13p ps=50.52u w=50u l=0.7u
X556 a_17684_168611# ESD_RAIL ESD_RAIL VSS nfet_06v0 ad=13p pd=50.52u as=13p ps=50.52u w=50u l=0.7u
X557 ESD_RAIL ESD_RAIL a_17684_168611# VSS nfet_06v0 ad=13p pd=50.52u as=13p ps=50.52u w=50u l=0.7u
X558 a_17684_168611# a_17684_168611# a_17684_180275# VSS nfet_06v0 ad=13p pd=50.52u as=13p ps=50.52u w=50u l=0.7u
X559 ESD_RAIL a_20789_137064# a_18245_110628# ESD_RAIL pfet_06v0 ad=1.3p pd=5.52u as=1.3p ps=5.52u w=5u l=0.7u
X560 BIAS_P_0 BIAS_P_1 VSS ppolyf_u_1k r_width=1u r_length=12.5u
X561 ESD_RAIL a_18245_110628# VSS VSS nfet_06v0 ad=13p pd=50.52u as=13p ps=50.52u w=50u l=0.7u
X562 ESD_RAIL a_18245_110628# VSS VSS nfet_06v0 ad=13p pd=50.52u as=13p ps=50.52u w=50u l=0.7u
X563 ESD_RAIL ESD_RAIL a_17684_168611# VSS nfet_06v0 ad=13p pd=50.52u as=13p ps=50.52u w=50u l=0.7u
X564 ESD_RAIL a_18245_110628# VSS VSS nfet_06v0 ad=13p pd=50.52u as=13p ps=50.52u w=50u l=0.7u
X565 a_17684_168611# ESD_RAIL ESD_RAIL VSS nfet_06v0 ad=13p pd=50.52u as=13p ps=50.52u w=50u l=0.7u
X566 a_17684_168611# a_17684_168611# a_17684_180275# VSS nfet_06v0 ad=13p pd=50.52u as=13p ps=50.52u w=50u l=0.7u
X567 VSS a_17684_180275# a_17684_180275# VSS nfet_06v0 ad=13p pd=50.52u as=13p ps=50.52u w=50u l=0.7u
X568 ESD_RAIL ESD_RAIL a_17684_168611# VSS nfet_06v0 ad=13p pd=50.52u as=13p ps=50.52u w=50u l=0.7u
X569 a_17684_168611# ESD_RAIL ESD_RAIL VSS nfet_06v0 ad=13p pd=50.52u as=13p ps=50.52u w=50u l=0.7u
X570 a_17684_180275# a_17684_168611# a_17684_168611# VSS nfet_06v0 ad=13p pd=50.52u as=13p ps=50.52u w=50u l=0.7u
X571 ESD_RAIL ESD_RAIL a_17684_168611# VSS nfet_06v0 ad=13p pd=50.52u as=13p ps=50.52u w=50u l=0.7u
X572 a_17684_168611# ESD_RAIL ESD_RAIL VSS nfet_06v0 ad=13p pd=50.52u as=13p ps=50.52u w=50u l=0.7u
X573 BIAS_N_6 VCM VSS ppolyf_u_1k r_width=1u r_length=12.5u
X574 a_17684_168611# ESD_RAIL ESD_RAIL VSS nfet_06v0 ad=13p pd=50.52u as=13p ps=50.52u w=50u l=0.7u
X575 a_17684_180275# a_17684_168611# a_17684_168611# VSS nfet_06v0 ad=13p pd=50.52u as=13p ps=50.52u w=50u l=0.7u
X576 ESD_RAIL ESD_RAIL a_17684_168611# VSS nfet_06v0 ad=13p pd=50.52u as=13p ps=50.52u w=50u l=0.7u
X577 a_17684_168611# ESD_RAIL ESD_RAIL VSS nfet_06v0 ad=13p pd=50.52u as=13p ps=50.52u w=50u l=0.7u
X578 a_17684_180275# a_17684_180275# VSS VSS nfet_06v0 ad=13p pd=50.52u as=13p ps=50.52u w=50u l=0.7u
X579 ESD_RAIL ESD_RAIL a_17684_168611# VSS nfet_06v0 ad=13p pd=50.52u as=13p ps=50.52u w=50u l=0.7u
X580 a_17684_168611# ESD_RAIL ESD_RAIL VSS nfet_06v0 ad=13p pd=50.52u as=13p ps=50.52u w=50u l=0.7u
X581 a_17684_180275# a_17684_168611# a_17684_168611# VSS nfet_06v0 ad=13p pd=50.52u as=13p ps=50.52u w=50u l=0.7u
X582 a_17684_168611# a_17684_168611# a_17684_180275# VSS nfet_06v0 ad=13p pd=50.52u as=13p ps=50.52u w=50u l=0.7u
X583 a_17005_152385# a_29878_152105# ESD_RAIL ppolyf_u r_width=0.8u r_length=63.855u
X584 a_17684_180275# a_17684_180275# VSS VSS nfet_06v0 ad=13p pd=50.52u as=13p ps=50.52u w=50u l=0.7u
X585 a_17684_168611# ESD_RAIL ESD_RAIL VSS nfet_06v0 ad=13p pd=50.52u as=13p ps=50.52u w=50u l=0.7u
X586 VSS a_18245_110628# ESD_RAIL VSS nfet_06v0 ad=13p pd=50.52u as=13p ps=50.52u w=50u l=0.7u
X587 a_19813_137064# a_17005_151545# ESD_RAIL ESD_RAIL pfet_06v0 ad=1.3p pd=5.52u as=1.3p ps=5.52u w=5u l=0.7u
X588 a_17684_168611# a_17684_168611# a_17684_180275# VSS nfet_06v0 ad=13p pd=50.52u as=13p ps=50.52u w=50u l=0.7u
X589 VSS a_18245_110628# ESD_RAIL VSS nfet_06v0 ad=13p pd=50.52u as=13p ps=50.52u w=50u l=0.7u
X590 VSS a_18245_110628# ESD_RAIL VSS nfet_06v0 ad=13p pd=50.52u as=13p ps=50.52u w=50u l=0.7u
X591 a_17684_168611# a_17684_168611# a_17684_180275# VSS nfet_06v0 ad=13p pd=50.52u as=13p ps=50.52u w=50u l=0.7u
X592 a_17684_168611# ESD_RAIL ESD_RAIL VSS nfet_06v0 ad=13p pd=50.52u as=13p ps=50.52u w=50u l=0.7u
X593 VSS a_17684_180275# a_17684_180275# VSS nfet_06v0 ad=13p pd=50.52u as=13p ps=50.52u w=50u l=0.7u
X594 a_17684_180275# a_17684_168611# a_17684_168611# VSS nfet_06v0 ad=13p pd=50.52u as=13p ps=50.52u w=50u l=0.7u
X595 a_20789_137064# a_19813_137064# ESD_RAIL ESD_RAIL pfet_06v0 ad=2.2p pd=10.88u as=1.3p ps=5.52u w=5u l=0.7u
X596 ESD_RAIL a_17005_151545# a_19813_137064# ESD_RAIL pfet_06v0 ad=1.3p pd=5.52u as=1.3p ps=5.52u w=5u l=0.7u
X597 a_17684_180275# a_17684_168611# a_17684_168611# VSS nfet_06v0 ad=13p pd=50.52u as=13p ps=50.52u w=50u l=0.7u
X598 a_17684_180275# a_17684_168611# a_17684_168611# VSS nfet_06v0 ad=13p pd=50.52u as=13p ps=50.52u w=50u l=0.7u
X599 VSS a_17684_180275# a_17684_180275# VSS nfet_06v0 ad=13p pd=50.52u as=13p ps=50.52u w=50u l=0.7u
X600 ESD_RAIL ESD_RAIL a_17684_168611# VSS nfet_06v0 ad=13p pd=50.52u as=13p ps=50.52u w=50u l=0.7u
X601 a_17684_180275# a_17684_180275# VSS VSS nfet_06v0 ad=13p pd=50.52u as=13p ps=50.52u w=50u l=0.7u
X602 a_17684_180275# a_17684_180275# VSS VSS nfet_06v0 ad=13p pd=50.52u as=13p ps=50.52u w=50u l=0.7u
X603 a_17684_180275# a_17684_168611# a_17684_168611# VSS nfet_06v0 ad=13p pd=50.52u as=13p ps=50.52u w=50u l=0.7u
X604 ESD_RAIL ESD_RAIL a_17684_168611# VSS nfet_06v0 ad=13p pd=50.52u as=13p ps=50.52u w=50u l=0.7u
X605 a_17684_168611# a_17684_168611# a_17684_180275# VSS nfet_06v0 ad=13p pd=50.52u as=13p ps=50.52u w=50u l=0.7u
X606 a_17684_168611# a_17684_168611# a_17684_180275# VSS nfet_06v0 ad=13p pd=50.52u as=13p ps=50.52u w=50u l=0.7u
X607 PAD_P BIAS_P_0 VSS ppolyf_u_1k r_width=1u r_length=12.5u
X608 a_17684_180275# a_17684_168611# a_17684_168611# VSS nfet_06v0 ad=13p pd=50.52u as=13p ps=50.52u w=50u l=0.7u
X609 a_17684_168611# a_17684_168611# a_17684_180275# VSS nfet_06v0 ad=13p pd=50.52u as=13p ps=50.52u w=50u l=0.7u
X610 a_17684_180275# a_17684_168611# a_17684_168611# VSS nfet_06v0 ad=22p pd=0.10088m as=13p ps=50.52u w=50u l=0.7u
X611 a_17684_180275# a_17684_180275# VSS VSS nfet_06v0 ad=13p pd=50.52u as=13p ps=50.52u w=50u l=0.7u
X612 ESD_RAIL a_18245_110628# VSS VSS nfet_06v0 ad=13p pd=50.52u as=13p ps=50.52u w=50u l=0.7u
X613 VSS a_17684_180275# a_17684_180275# VSS nfet_06v0 ad=13p pd=50.52u as=13p ps=50.52u w=50u l=0.7u
X614 a_17684_168611# a_17684_168611# a_17684_180275# VSS nfet_06v0 ad=13p pd=50.52u as=13p ps=50.52u w=50u l=0.7u
X615 a_17684_168611# a_17684_168611# a_17684_180275# VSS nfet_06v0 ad=13p pd=50.52u as=13p ps=50.52u w=50u l=0.7u
X616 BIAS_N_2 BIAS_N_3 VSS ppolyf_u_1k r_width=1u r_length=12.5u
X617 ESD_RAIL a_18245_110628# VSS VSS nfet_06v0 ad=13p pd=50.52u as=13p ps=50.52u w=50u l=0.7u
X618 a_18245_110628# a_20789_137064# ESD_RAIL ESD_RAIL pfet_06v0 ad=1.3p pd=5.52u as=1.3p ps=5.52u w=5u l=0.7u
X619 a_17684_180275# a_17684_168611# a_17684_168611# VSS nfet_06v0 ad=13p pd=50.52u as=13p ps=50.52u w=50u l=0.7u
X620 a_17684_168611# a_17684_168611# a_17684_180275# VSS nfet_06v0 ad=13p pd=50.52u as=13p ps=50.52u w=50u l=0.7u
X621 BIAS_P_5 BIAS_P_6 VSS ppolyf_u_1k r_width=1u r_length=12.5u
X622 a_17684_168611# ESD_RAIL ESD_RAIL VSS nfet_06v0 ad=13p pd=50.52u as=13p ps=50.52u w=50u l=0.7u
X623 a_17684_168611# a_17684_168611# a_17684_180275# VSS nfet_06v0 ad=13p pd=50.52u as=13p ps=50.52u w=50u l=0.7u
X624 ESD_RAIL a_18245_110628# VSS VSS nfet_06v0 ad=13p pd=50.52u as=13p ps=50.52u w=50u l=0.7u
X625 a_17684_180275# a_17684_180275# VSS VSS nfet_06v0 ad=13p pd=50.52u as=13p ps=50.52u w=50u l=0.7u
X626 VSS a_17684_180275# a_17684_180275# VSS nfet_06v0 ad=13p pd=50.52u as=13p ps=50.52u w=50u l=0.7u
X627 a_17684_180275# a_17684_180275# VSS VSS nfet_06v0 ad=13p pd=50.52u as=13p ps=50.52u w=50u l=0.7u
X628 a_17684_180275# a_17684_180275# VSS VSS nfet_06v0 ad=13p pd=50.52u as=13p ps=50.52u w=50u l=0.7u
X629 a_17684_180275# a_17684_168611# a_17684_168611# VSS nfet_06v0 ad=13p pd=50.52u as=13p ps=50.52u w=50u l=0.7u
X630 a_17684_168611# a_17684_168611# a_17684_180275# VSS nfet_06v0 ad=13p pd=50.52u as=13p ps=50.52u w=50u l=0.7u
X631 a_17684_168611# ESD_RAIL ESD_RAIL VSS nfet_06v0 ad=13p pd=50.52u as=13p ps=50.52u w=50u l=0.7u
X632 VSS a_17684_180275# a_17684_180275# VSS nfet_06v0 ad=13p pd=50.52u as=13p ps=50.52u w=50u l=0.7u
X633 a_17684_180275# a_17684_180275# VSS VSS nfet_06v0 ad=13p pd=50.52u as=13p ps=50.52u w=50u l=0.7u
X634 a_17005_151825# a_29878_152105# ESD_RAIL ppolyf_u r_width=0.8u r_length=63.855u
X635 a_17684_180275# a_17684_180275# VSS VSS nfet_06v0 ad=13p pd=50.52u as=13p ps=50.52u w=50u l=0.7u
X636 a_17684_180275# a_17684_168611# a_17684_168611# VSS nfet_06v0 ad=13p pd=50.52u as=13p ps=50.52u w=50u l=0.7u
X637 ESD_RAIL ESD_RAIL a_17684_168611# VSS nfet_06v0 ad=13p pd=50.52u as=13p ps=50.52u w=50u l=0.7u
X638 ESD_RAIL ESD_RAIL a_17684_168611# VSS nfet_06v0 ad=13p pd=50.52u as=13p ps=50.52u w=50u l=0.7u
X639 a_17684_168611# a_17684_168611# a_17684_180275# VSS nfet_06v0 ad=13p pd=50.52u as=13p ps=50.52u w=50u l=0.7u
X640 ESD_RAIL a_20789_137064# a_18245_110628# ESD_RAIL pfet_06v0 ad=1.3p pd=5.52u as=1.3p ps=5.52u w=5u l=0.7u
X641 a_17684_180275# a_17684_180275# VSS VSS nfet_06v0 ad=13p pd=50.52u as=13p ps=50.52u w=50u l=0.7u
X642 ESD_RAIL a_18245_110628# VSS VSS nfet_06v0 ad=13p pd=50.52u as=13p ps=50.52u w=50u l=0.7u
X643 VSS a_17684_180275# a_17684_180275# VSS nfet_06v0 ad=13p pd=50.52u as=13p ps=50.52u w=50u l=0.7u
X644 a_17684_180275# a_17684_180275# VSS VSS nfet_06v0 ad=13p pd=50.52u as=13p ps=50.52u w=50u l=0.7u
X645 a_17684_180275# a_17684_180275# VSS VSS nfet_06v0 ad=13p pd=50.52u as=13p ps=50.52u w=50u l=0.7u
X646 a_17684_168611# a_17684_168611# a_17684_180275# VSS nfet_06v0 ad=13p pd=50.52u as=13p ps=50.52u w=50u l=0.7u
X647 a_17684_180275# a_17684_180275# VSS VSS nfet_06v0 ad=13p pd=50.52u as=13p ps=50.52u w=50u l=0.7u
X648 a_17684_180275# a_17684_168611# a_17684_168611# VSS nfet_06v0 ad=13p pd=50.52u as=13p ps=50.52u w=50u l=0.7u
X649 VSS a_17684_180275# a_17684_180275# VSS nfet_06v0 ad=13p pd=50.52u as=13p ps=50.52u w=50u l=0.7u
X650 VSS a_17684_180275# a_17684_180275# VSS nfet_06v0 ad=13p pd=50.52u as=13p ps=50.52u w=50u l=0.7u
X651 VSS a_18245_110628# ESD_RAIL VSS nfet_06v0 ad=13p pd=50.52u as=13p ps=50.52u w=50u l=0.7u
X652 ESD_RAIL ESD_RAIL a_17684_168611# VSS nfet_06v0 ad=13p pd=50.52u as=13p ps=50.52u w=50u l=0.7u
X653 a_17684_168611# a_17684_168611# a_17684_180275# VSS nfet_06v0 ad=13p pd=50.52u as=13p ps=50.52u w=50u l=0.7u
X654 ESD_RAIL a_19813_137064# a_20789_137064# ESD_RAIL pfet_06v0 ad=1.3p pd=5.52u as=1.3p ps=5.52u w=5u l=0.7u
X655 a_17684_168611# ESD_RAIL ESD_RAIL VSS nfet_06v0 ad=13p pd=50.52u as=13p ps=50.52u w=50u l=0.7u
X656 a_17684_180275# a_17684_180275# VSS VSS nfet_06v0 ad=13p pd=50.52u as=13p ps=50.52u w=50u l=0.7u
X657 a_17684_180275# a_17684_180275# VSS VSS nfet_06v0 ad=13p pd=50.52u as=13p ps=50.52u w=50u l=0.7u
X658 a_17684_180275# a_17684_168611# a_17684_168611# VSS nfet_06v0 ad=13p pd=50.52u as=13p ps=50.52u w=50u l=0.7u
X659 VSS a_17684_180275# a_17684_180275# VSS nfet_06v0 ad=13p pd=50.52u as=13p ps=50.52u w=50u l=0.7u
X660 VSS a_18245_110628# ESD_RAIL VSS nfet_06v0 ad=13p pd=50.52u as=13p ps=50.52u w=50u l=0.7u
X661 VSS a_17684_180275# a_17684_180275# VSS nfet_06v0 ad=13p pd=50.52u as=13p ps=50.52u w=50u l=0.7u
D13 VSS PAD_N diode_nd2ps_06v0 pj=51.8u area=22.5p
X662 a_18245_110628# a_20789_137064# ESD_RAIL ESD_RAIL pfet_06v0 ad=1.3p pd=5.52u as=1.3p ps=5.52u w=5u l=0.7u
X663 ESD_RAIL a_20789_137064# a_18245_110628# ESD_RAIL pfet_06v0 ad=1.3p pd=5.52u as=1.3p ps=5.52u w=5u l=0.7u
X664 ESD_RAIL ESD_RAIL a_17684_168611# VSS nfet_06v0 ad=13p pd=50.52u as=13p ps=50.52u w=50u l=0.7u
X665 a_17684_180275# a_17684_180275# VSS VSS nfet_06v0 ad=13p pd=50.52u as=13p ps=50.52u w=50u l=0.7u
X666 a_17684_180275# a_17684_180275# VSS VSS nfet_06v0 ad=13p pd=50.52u as=13p ps=50.52u w=50u l=0.7u
X667 ESD_RAIL ESD_RAIL a_17684_168611# VSS nfet_06v0 ad=13p pd=50.52u as=13p ps=50.52u w=50u l=0.7u
X668 a_17684_168611# ESD_RAIL ESD_RAIL VSS nfet_06v0 ad=13p pd=50.52u as=13p ps=50.52u w=50u l=0.7u
X669 a_17684_180275# a_17684_168611# a_17684_168611# VSS nfet_06v0 ad=13p pd=50.52u as=13p ps=50.52u w=50u l=0.7u
X670 ESD_RAIL ESD_RAIL a_17684_168611# VSS nfet_06v0 ad=13p pd=50.52u as=13p ps=50.52u w=50u l=0.7u
X671 VSS a_17684_180275# a_17684_180275# VSS nfet_06v0 ad=13p pd=50.52u as=13p ps=50.52u w=50u l=0.7u
X672 a_17684_180275# a_17684_180275# VSS VSS nfet_06v0 ad=13p pd=50.52u as=13p ps=50.52u w=50u l=0.7u
X673 VSS a_17684_180275# a_17684_180275# VSS nfet_06v0 ad=13p pd=50.52u as=13p ps=50.52u w=50u l=0.7u
X674 a_17684_168611# a_17684_168611# a_17684_180275# VSS nfet_06v0 ad=13p pd=50.52u as=13p ps=50.52u w=50u l=0.7u
X675 ESD_RAIL a_18245_110628# VSS VSS nfet_06v0 ad=22p pd=0.10088m as=13p ps=50.52u w=50u l=0.7u
X676 a_17684_180275# a_17684_180275# VSS VSS nfet_06v0 ad=13p pd=50.52u as=13p ps=50.52u w=50u l=0.7u
X677 ESD_RAIL ESD_RAIL a_17684_168611# VSS nfet_06v0 ad=13p pd=50.52u as=13p ps=50.52u w=50u l=0.7u
X678 a_17684_168611# ESD_RAIL ESD_RAIL VSS nfet_06v0 ad=13p pd=50.52u as=13p ps=50.52u w=50u l=0.7u
X679 ESD_RAIL ESD_RAIL a_17684_168611# VSS nfet_06v0 ad=13p pd=50.52u as=13p ps=50.52u w=50u l=0.7u
X680 VSS a_17684_180275# a_17684_180275# VSS nfet_06v0 ad=13p pd=50.52u as=13p ps=50.52u w=50u l=0.7u
X681 a_17005_152945# a_29878_153225# ESD_RAIL ppolyf_u r_width=0.8u r_length=63.855u
X682 ESD_RAIL ESD_RAIL a_17684_168611# VSS nfet_06v0 ad=13p pd=50.52u as=13p ps=50.52u w=50u l=0.7u
X683 a_17684_180275# a_17684_180275# VSS VSS nfet_06v0 ad=13p pd=50.52u as=13p ps=50.52u w=50u l=0.7u
X684 VSS a_17684_180275# a_17684_180275# VSS nfet_06v0 ad=13p pd=50.52u as=13p ps=50.52u w=50u l=0.7u
X685 a_17684_180275# a_17684_168611# a_17684_168611# VSS nfet_06v0 ad=13p pd=50.52u as=13p ps=50.52u w=50u l=0.7u
X686 ESD_RAIL ESD_RAIL a_17684_168611# VSS nfet_06v0 ad=13p pd=50.52u as=13p ps=50.52u w=50u l=0.7u
X687 a_17684_168611# ESD_RAIL ESD_RAIL VSS nfet_06v0 ad=13p pd=50.52u as=13p ps=50.52u w=50u l=0.7u
X688 a_17684_180275# a_17684_180275# VSS VSS nfet_06v0 ad=13p pd=50.52u as=13p ps=50.52u w=50u l=0.7u
X689 a_17684_168611# a_17684_168611# a_17684_180275# VSS nfet_06v0 ad=13p pd=50.52u as=13p ps=50.52u w=50u l=0.7u
X690 a_17684_168611# a_17684_168611# a_17684_180275# VSS nfet_06v0 ad=13p pd=50.52u as=13p ps=50.52u w=50u l=0.7u
X691 ESD_RAIL ESD_RAIL a_17684_168611# VSS nfet_06v0 ad=13p pd=50.52u as=13p ps=50.52u w=50u l=0.7u
X692 a_17684_180275# a_17684_168611# a_17684_168611# VSS nfet_06v0 ad=13p pd=50.52u as=13p ps=50.52u w=50u l=0.7u
X693 ESD_RAIL ESD_RAIL a_17684_168611# VSS nfet_06v0 ad=13p pd=50.52u as=13p ps=50.52u w=50u l=0.7u
X694 a_17684_168611# ESD_RAIL ESD_RAIL VSS nfet_06v0 ad=13p pd=50.52u as=13p ps=50.52u w=50u l=0.7u
X695 VSS a_17684_180275# a_17684_180275# VSS nfet_06v0 ad=13p pd=50.52u as=13p ps=50.52u w=50u l=0.7u
X696 VSS a_17684_180275# a_17684_180275# VSS nfet_06v0 ad=13p pd=50.52u as=13p ps=50.52u w=50u l=0.7u
X697 a_17684_168611# ESD_RAIL ESD_RAIL VSS nfet_06v0 ad=13p pd=50.52u as=13p ps=50.52u w=50u l=0.7u
X698 a_17684_180275# a_17684_180275# VSS VSS nfet_06v0 ad=13p pd=50.52u as=13p ps=50.52u w=50u l=0.7u
X699 ESD_RAIL ESD_RAIL a_17684_168611# VSS nfet_06v0 ad=13p pd=50.52u as=13p ps=50.52u w=50u l=0.7u
X700 a_20789_137064# a_19813_137064# ESD_RAIL ESD_RAIL pfet_06v0 ad=1.3p pd=5.52u as=1.3p ps=5.52u w=5u l=0.7u
X701 ESD_RAIL ESD_RAIL a_17684_168611# VSS nfet_06v0 ad=13p pd=50.52u as=13p ps=50.52u w=50u l=0.7u
X702 VSS a_17684_180275# a_17684_180275# VSS nfet_06v0 ad=13p pd=50.52u as=13p ps=50.52u w=50u l=0.7u
X703 ESD_RAIL a_18245_110628# VSS VSS nfet_06v0 ad=13p pd=50.52u as=13p ps=50.52u w=50u l=0.7u
X704 a_17684_168611# ESD_RAIL ESD_RAIL VSS nfet_06v0 ad=13p pd=50.52u as=13p ps=50.52u w=50u l=0.7u
X705 a_17684_168611# a_17684_168611# a_17684_180275# VSS nfet_06v0 ad=13p pd=50.52u as=13p ps=50.52u w=50u l=0.7u
X706 a_17684_180275# a_17684_180275# VSS VSS nfet_06v0 ad=13p pd=50.52u as=13p ps=50.52u w=50u l=0.7u
X707 VSS a_17684_180275# a_17684_180275# VSS nfet_06v0 ad=13p pd=50.52u as=13p ps=50.52u w=50u l=0.7u
X708 a_17684_180275# a_17684_168611# a_17684_168611# VSS nfet_06v0 ad=13p pd=50.52u as=13p ps=50.52u w=50u l=0.7u
X709 a_17684_168611# ESD_RAIL ESD_RAIL VSS nfet_06v0 ad=13p pd=50.52u as=13p ps=50.52u w=50u l=0.7u
X710 a_17684_180275# a_17684_180275# VSS VSS nfet_06v0 ad=13p pd=50.52u as=13p ps=50.52u w=50u l=0.7u
X711 ESD_RAIL a_18245_110628# VSS VSS nfet_06v0 ad=13p pd=50.52u as=13p ps=50.52u w=50u l=0.7u
X712 ESD_RAIL ESD_RAIL a_17684_168611# VSS nfet_06v0 ad=13p pd=50.52u as=13p ps=50.52u w=50u l=0.7u
X713 ESD_RAIL ESD_RAIL a_17684_168611# VSS nfet_06v0 ad=13p pd=50.52u as=13p ps=50.52u w=50u l=0.7u
X714 ESD_RAIL a_18245_110628# VSS VSS nfet_06v0 ad=13p pd=50.52u as=13p ps=50.52u w=50u l=0.7u
X715 VSS a_17684_180275# a_17684_180275# VSS nfet_06v0 ad=13p pd=50.52u as=13p ps=50.52u w=50u l=0.7u
X716 VSS a_18245_110628# ESD_RAIL VSS nfet_06v0 ad=13p pd=50.52u as=13p ps=50.52u w=50u l=0.7u
X717 a_17684_168611# ESD_RAIL ESD_RAIL VSS nfet_06v0 ad=13p pd=50.52u as=13p ps=50.52u w=50u l=0.7u
X718 a_17684_168611# ESD_RAIL ESD_RAIL VSS nfet_06v0 ad=13p pd=50.52u as=13p ps=50.52u w=50u l=0.7u
X719 ESD_RAIL ESD_RAIL a_17684_168611# VSS nfet_06v0 ad=13p pd=50.52u as=13p ps=50.52u w=50u l=0.7u
X720 a_17684_180275# a_17684_180275# VSS VSS nfet_06v0 ad=13p pd=50.52u as=13p ps=50.52u w=50u l=0.7u
X721 ESD_RAIL ESD_RAIL a_17684_168611# VSS nfet_06v0 ad=13p pd=50.52u as=13p ps=50.52u w=50u l=0.7u
X722 VSS a_17684_180275# a_17684_180275# VSS nfet_06v0 ad=13p pd=50.52u as=13p ps=50.52u w=50u l=0.7u
X723 a_17684_168611# a_17684_168611# a_17684_180275# VSS nfet_06v0 ad=13p pd=50.52u as=13p ps=50.52u w=50u l=0.7u
X724 a_17684_168611# ESD_RAIL ESD_RAIL VSS nfet_06v0 ad=13p pd=50.52u as=13p ps=50.52u w=50u l=0.7u
X725 ESD_RAIL ESD_RAIL a_17684_168611# VSS nfet_06v0 ad=13p pd=50.52u as=13p ps=50.52u w=50u l=0.7u
X726 a_17684_180275# a_17684_180275# VSS VSS nfet_06v0 ad=13p pd=50.52u as=13p ps=50.52u w=50u l=0.7u
X727 a_17684_180275# a_17684_180275# VSS VSS nfet_06v0 ad=13p pd=50.52u as=13p ps=50.52u w=50u l=0.7u
X728 a_17005_154065# a_29878_154345# ESD_RAIL ppolyf_u r_width=0.8u r_length=63.855u
D14 PAD_P ESD_RAIL diode_pd2nw_06v0 pj=51.8u area=22.5p
X729 a_17684_168611# ESD_RAIL ESD_RAIL VSS nfet_06v0 ad=13p pd=50.52u as=13p ps=50.52u w=50u l=0.7u
X730 a_17684_180275# a_17684_168611# a_17684_168611# VSS nfet_06v0 ad=13p pd=50.52u as=13p ps=50.52u w=50u l=0.7u
D15 PAD_N ESD_RAIL diode_pd2nw_06v0 pj=51.8u area=22.5p
X731 a_17684_180275# a_17684_180275# VSS VSS nfet_06v0 ad=13p pd=50.52u as=13p ps=50.52u w=50u l=0.7u
X732 a_17684_168611# a_17684_168611# a_17684_180275# VSS nfet_06v0 ad=13p pd=50.52u as=13p ps=50.52u w=50u l=0.7u
X733 ESD_RAIL ESD_RAIL a_17684_168611# VSS nfet_06v0 ad=13p pd=50.52u as=13p ps=50.52u w=50u l=0.7u
D16 PAD_P ESD_RAIL diode_pd2nw_06v0 pj=51.8u area=22.5p
X734 ESD_RAIL a_18245_110628# VSS VSS nfet_06v0 ad=13p pd=50.52u as=13p ps=50.52u w=50u l=0.7u
X735 a_17684_168611# ESD_RAIL ESD_RAIL VSS nfet_06v0 ad=13p pd=50.52u as=13p ps=50.52u w=50u l=0.7u
X736 a_17684_180275# a_17684_168611# a_17684_168611# VSS nfet_06v0 ad=13p pd=50.52u as=13p ps=50.52u w=50u l=0.7u
X737 a_17684_168611# ESD_RAIL ESD_RAIL VSS nfet_06v0 ad=13p pd=50.52u as=13p ps=50.52u w=50u l=0.7u
X738 a_17684_180275# a_17684_168611# a_17684_168611# VSS nfet_06v0 ad=13p pd=50.52u as=13p ps=50.52u w=50u l=0.7u
X739 a_17684_180275# a_17684_180275# VSS VSS nfet_06v0 ad=13p pd=50.52u as=13p ps=50.52u w=50u l=0.7u
X740 ESD_RAIL ESD_RAIL a_17684_168611# VSS nfet_06v0 ad=13p pd=50.52u as=13p ps=50.52u w=50u l=0.7u
X741 a_17684_168611# ESD_RAIL ESD_RAIL VSS nfet_06v0 ad=13p pd=50.52u as=13p ps=50.52u w=50u l=0.7u
X742 VSS ESD_RAIL VSS ppolyf_u_1k_6p0 r_width=1u r_length=9.98874m
X743 a_17684_180275# a_17684_168611# a_17684_168611# VSS nfet_06v0 ad=13p pd=50.52u as=13p ps=50.52u w=50u l=0.7u
X744 ESD_RAIL ESD_RAIL a_17684_168611# VSS nfet_06v0 ad=13p pd=50.52u as=13p ps=50.52u w=50u l=0.7u
X745 a_17684_168611# ESD_RAIL ESD_RAIL VSS nfet_06v0 ad=13p pd=50.52u as=13p ps=50.52u w=50u l=0.7u
X746 a_17684_168611# a_17684_168611# a_17684_180275# VSS nfet_06v0 ad=13p pd=50.52u as=13p ps=50.52u w=50u l=0.7u
X747 a_17684_180275# a_17684_168611# a_17684_168611# VSS nfet_06v0 ad=13p pd=50.52u as=13p ps=50.52u w=50u l=0.7u
X748 ESD_RAIL ESD_RAIL a_17684_168611# VSS nfet_06v0 ad=13p pd=50.52u as=13p ps=50.52u w=50u l=0.7u
X749 a_17684_180275# a_17684_168611# a_17684_168611# VSS nfet_06v0 ad=13p pd=50.52u as=13p ps=50.52u w=50u l=0.7u
X750 ESD_RAIL a_18245_110628# VSS VSS nfet_06v0 ad=13p pd=50.52u as=13p ps=50.52u w=50u l=0.7u
X751 a_17684_168611# ESD_RAIL ESD_RAIL VSS nfet_06v0 ad=13p pd=50.52u as=13p ps=50.52u w=50u l=0.7u
X752 ESD_RAIL ESD_RAIL a_17684_168611# VSS nfet_06v0 ad=13p pd=50.52u as=13p ps=50.52u w=50u l=0.7u
X753 a_17684_168611# a_17684_168611# a_17684_180275# VSS nfet_06v0 ad=13p pd=50.52u as=13p ps=50.52u w=50u l=0.7u
X754 a_17684_180275# a_17684_168611# a_17684_168611# VSS nfet_06v0 ad=13p pd=50.52u as=13p ps=50.52u w=50u l=0.7u
X755 a_17684_168611# a_17684_168611# a_17684_180275# VSS nfet_06v0 ad=13p pd=50.52u as=13p ps=50.52u w=50u l=0.7u
X756 a_17684_180275# a_17684_180275# VSS VSS nfet_06v0 ad=13p pd=50.52u as=13p ps=50.52u w=50u l=0.7u
X757 ESD_RAIL ESD_RAIL a_17684_168611# VSS nfet_06v0 ad=13p pd=50.52u as=13p ps=50.52u w=50u l=0.7u
X758 a_17684_168611# ESD_RAIL ESD_RAIL VSS nfet_06v0 ad=13p pd=50.52u as=13p ps=50.52u w=50u l=0.7u
X759 VSS a_17684_180275# a_17684_180275# VSS nfet_06v0 ad=13p pd=50.52u as=13p ps=50.52u w=50u l=0.7u
X760 ESD_RAIL ESD_RAIL a_17684_168611# VSS nfet_06v0 ad=13p pd=50.52u as=13p ps=50.52u w=50u l=0.7u
X761 a_17684_168611# a_17684_168611# a_17684_180275# VSS nfet_06v0 ad=13p pd=50.52u as=13p ps=50.52u w=50u l=0.7u
X762 BIAS_P_4 BIAS_P_5 VSS ppolyf_u_1k r_width=1u r_length=12.5u
X763 a_17684_180275# a_17684_180275# VSS VSS nfet_06v0 ad=13p pd=50.52u as=13p ps=50.52u w=50u l=0.7u
X764 ESD_RAIL ESD_RAIL a_17684_168611# VSS nfet_06v0 ad=13p pd=50.52u as=13p ps=50.52u w=50u l=0.7u
X765 VSS a_17684_180275# a_17684_180275# VSS nfet_06v0 ad=13p pd=50.52u as=13p ps=50.52u w=50u l=0.7u
X766 a_17684_168611# a_17684_168611# a_17684_180275# VSS nfet_06v0 ad=13p pd=50.52u as=13p ps=50.52u w=50u l=0.7u
X767 a_17684_180275# a_17684_168611# a_17684_168611# VSS nfet_06v0 ad=13p pd=50.52u as=13p ps=50.52u w=50u l=0.7u
X768 BIAS_N_3 BIAS_N_4 VSS ppolyf_u_1k r_width=1u r_length=12.5u
X769 VSS a_19813_137064# a_20789_137064# VSS nfet_06v0 ad=1.3p pd=5.52u as=1.3p ps=5.52u w=5u l=0.7u
X770 ESD_RAIL ESD_RAIL a_17684_168611# VSS nfet_06v0 ad=13p pd=50.52u as=13p ps=50.52u w=50u l=0.7u
X771 a_17684_180275# a_17684_180275# VSS VSS nfet_06v0 ad=13p pd=50.52u as=13p ps=50.52u w=50u l=0.7u
X772 a_17684_168611# a_17684_168611# a_17684_180275# VSS nfet_06v0 ad=13p pd=50.52u as=13p ps=50.52u w=50u l=0.7u
X773 a_17684_180275# a_17684_168611# a_17684_168611# VSS nfet_06v0 ad=13p pd=50.52u as=13p ps=50.52u w=50u l=0.7u
X774 VSS a_17684_180275# a_17684_180275# VSS nfet_06v0 ad=13p pd=50.52u as=13p ps=50.52u w=50u l=0.7u
X775 a_17684_180275# a_17684_180275# VSS VSS nfet_06v0 ad=13p pd=50.52u as=13p ps=50.52u w=50u l=0.7u
X776 a_17684_180275# a_17684_168611# a_17684_168611# VSS nfet_06v0 ad=13p pd=50.52u as=13p ps=50.52u w=50u l=0.7u
X777 ESD_RAIL a_18245_110628# VSS VSS nfet_06v0 ad=13p pd=50.52u as=13p ps=50.52u w=50u l=0.7u
X778 VSS a_17684_180275# a_17684_180275# VSS nfet_06v0 ad=13p pd=50.52u as=13p ps=50.52u w=50u l=0.7u
X779 VSS a_17684_180275# a_17684_180275# VSS nfet_06v0 ad=13p pd=50.52u as=13p ps=50.52u w=50u l=0.7u
X780 a_17684_180275# a_17684_180275# VSS VSS nfet_06v0 ad=13p pd=50.52u as=13p ps=50.52u w=50u l=0.7u
X781 VSS a_20789_137064# a_18245_110628# VSS nfet_06v0 ad=1.3p pd=5.52u as=1.3p ps=5.52u w=5u l=0.7u
X782 a_17684_180275# a_17684_168611# a_17684_168611# VSS nfet_06v0 ad=13p pd=50.52u as=13p ps=50.52u w=50u l=0.7u
X783 a_17684_168611# a_17684_168611# a_17684_180275# VSS nfet_06v0 ad=13p pd=50.52u as=13p ps=50.52u w=50u l=0.7u
X784 VSS a_18245_110628# ESD_RAIL VSS nfet_06v0 ad=13p pd=50.52u as=13p ps=50.52u w=50u l=0.7u
X785 VSS a_18245_110628# ESD_RAIL VSS nfet_06v0 ad=13p pd=50.52u as=13p ps=50.52u w=50u l=0.7u
X786 VSS a_20789_137064# a_18245_110628# VSS nfet_06v0 ad=1.3p pd=5.52u as=1.3p ps=5.52u w=5u l=0.7u
X787 ESD_RAIL ESD_RAIL a_17684_168611# VSS nfet_06v0 ad=13p pd=50.52u as=13p ps=50.52u w=50u l=0.7u
X788 VSS a_17684_180275# a_17684_180275# VSS nfet_06v0 ad=13p pd=50.52u as=13p ps=50.52u w=50u l=0.7u
X789 a_17684_168611# ESD_RAIL ESD_RAIL VSS nfet_06v0 ad=13p pd=50.52u as=13p ps=50.52u w=50u l=0.7u
X790 a_17684_168611# a_17684_168611# a_17684_180275# VSS nfet_06v0 ad=13p pd=50.52u as=13p ps=50.52u w=50u l=0.7u
X791 a_17684_168611# a_17684_168611# a_17684_180275# VSS nfet_06v0 ad=13p pd=50.52u as=13p ps=50.52u w=50u l=0.7u
X792 ESD_RAIL a_20789_137064# a_18245_110628# ESD_RAIL pfet_06v0 ad=1.3p pd=5.52u as=1.3p ps=5.52u w=5u l=0.7u
X793 a_17684_180275# a_17684_180275# VSS VSS nfet_06v0 ad=13p pd=50.52u as=13p ps=50.52u w=50u l=0.7u
X794 ESD_RAIL ESD_RAIL a_17684_168611# VSS nfet_06v0 ad=13p pd=50.52u as=13p ps=50.52u w=50u l=0.7u
X795 VSS a_17684_180275# a_17684_180275# VSS nfet_06v0 ad=13p pd=50.52u as=13p ps=50.52u w=50u l=0.7u
X796 a_17684_180275# a_17684_180275# VSS VSS nfet_06v0 ad=13p pd=50.52u as=13p ps=50.52u w=50u l=0.7u
X797 VSS a_17684_180275# a_17684_180275# VSS nfet_06v0 ad=13p pd=50.52u as=13p ps=50.52u w=50u l=0.7u
X798 a_17684_168611# ESD_RAIL ESD_RAIL VSS nfet_06v0 ad=13p pd=50.52u as=13p ps=50.52u w=50u l=0.7u
X799 a_17684_168611# a_17684_168611# a_17684_180275# VSS nfet_06v0 ad=13p pd=50.52u as=13p ps=50.52u w=50u l=0.7u
X800 a_17684_180275# a_17684_180275# VSS VSS nfet_06v0 ad=13p pd=50.52u as=13p ps=50.52u w=50u l=0.7u
X801 ESD_RAIL ESD_RAIL a_17684_168611# VSS nfet_06v0 ad=13p pd=50.52u as=13p ps=50.52u w=50u l=0.7u
X802 VSS a_17684_180275# a_17684_180275# VSS nfet_06v0 ad=13p pd=50.52u as=13p ps=50.52u w=50u l=0.7u
X803 a_17684_180275# a_17684_168611# a_17684_168611# VSS nfet_06v0 ad=13p pd=50.52u as=13p ps=50.52u w=50u l=0.7u
X804 a_20789_137064# a_19813_137064# VSS VSS nfet_06v0 ad=1.3p pd=5.52u as=1.3p ps=5.52u w=5u l=0.7u
X805 a_17684_168611# ESD_RAIL ESD_RAIL VSS nfet_06v0 ad=13p pd=50.52u as=13p ps=50.52u w=50u l=0.7u
X806 a_17684_180275# a_17684_180275# VSS VSS nfet_06v0 ad=13p pd=50.52u as=13p ps=50.52u w=50u l=0.7u
X807 a_17684_180275# a_17684_180275# VSS VSS nfet_06v0 ad=13p pd=50.52u as=13p ps=50.52u w=50u l=0.7u
X808 ESD_RAIL ESD_RAIL a_17684_168611# VSS nfet_06v0 ad=13p pd=50.52u as=13p ps=50.52u w=50u l=0.7u
X809 a_17684_180275# a_17684_168611# a_17684_168611# VSS nfet_06v0 ad=13p pd=50.52u as=13p ps=50.52u w=50u l=0.7u
X810 a_17684_180275# a_17684_168611# a_17684_168611# VSS nfet_06v0 ad=13p pd=50.52u as=13p ps=50.52u w=50u l=0.7u
X811 VSS a_18245_110628# ESD_RAIL VSS nfet_06v0 ad=13p pd=50.52u as=13p ps=50.52u w=50u l=0.7u
X812 VSS a_17684_180275# a_17684_180275# VSS nfet_06v0 ad=13p pd=50.52u as=13p ps=50.52u w=50u l=0.7u
X813 a_17684_168611# ESD_RAIL ESD_RAIL VSS nfet_06v0 ad=13p pd=50.52u as=13p ps=50.52u w=50u l=0.7u
X814 BIAS_N_5 BIAS_N_6 VSS ppolyf_u_1k r_width=1u r_length=12.5u
X815 a_17684_168611# ESD_RAIL ESD_RAIL VSS nfet_06v0 ad=13p pd=50.52u as=13p ps=50.52u w=50u l=0.7u
X816 a_17684_180275# a_17684_180275# VSS VSS nfet_06v0 ad=13p pd=50.52u as=13p ps=50.52u w=50u l=0.7u
X817 VSS a_17684_180275# a_17684_180275# VSS nfet_06v0 ad=13p pd=50.52u as=13p ps=50.52u w=50u l=0.7u
X818 a_17684_180275# a_17684_180275# VSS VSS nfet_06v0 ad=13p pd=50.52u as=13p ps=50.52u w=50u l=0.7u
X819 ESD_RAIL ESD_RAIL a_17684_168611# VSS nfet_06v0 ad=13p pd=50.52u as=13p ps=50.52u w=50u l=0.7u
X820 VSS a_17684_180275# a_17684_180275# VSS nfet_06v0 ad=13p pd=50.52u as=13p ps=50.52u w=50u l=0.7u
X821 a_17684_180275# a_17684_180275# VSS VSS nfet_06v0 ad=13p pd=50.52u as=13p ps=50.52u w=50u l=0.7u
X822 VSS a_17684_180275# a_17684_180275# VSS nfet_06v0 ad=13p pd=50.52u as=13p ps=50.52u w=50u l=0.7u
X823 VSS a_17684_180275# a_17684_180275# VSS nfet_06v0 ad=13p pd=50.52u as=13p ps=50.52u w=50u l=0.7u
X824 a_17684_168611# ESD_RAIL ESD_RAIL VSS nfet_06v0 ad=13p pd=50.52u as=13p ps=50.52u w=50u l=0.7u
X825 a_17684_180275# a_17684_180275# VSS VSS nfet_06v0 ad=13p pd=50.52u as=13p ps=50.52u w=50u l=0.7u
X826 VSS a_17684_180275# a_17684_180275# VSS nfet_06v0 ad=13p pd=50.52u as=13p ps=50.52u w=50u l=0.7u
X827 ESD_RAIL a_18245_110628# VSS VSS nfet_06v0 ad=13p pd=50.52u as=13p ps=50.52u w=50u l=0.7u
X828 ESD_RAIL ESD_RAIL a_17684_168611# VSS nfet_06v0 ad=13p pd=50.52u as=13p ps=50.52u w=50u l=0.7u
X829 ESD_RAIL ESD_RAIL a_17684_168611# VSS nfet_06v0 ad=13p pd=50.52u as=13p ps=50.52u w=50u l=0.7u
X830 VSS a_17684_180275# a_17684_180275# VSS nfet_06v0 ad=13p pd=50.52u as=13p ps=50.52u w=50u l=0.7u
X831 a_17684_168611# ESD_RAIL ESD_RAIL VSS nfet_06v0 ad=13p pd=50.52u as=13p ps=50.52u w=50u l=0.7u
X832 ESD_RAIL a_18245_110628# VSS VSS nfet_06v0 ad=13p pd=50.52u as=13p ps=50.52u w=50u l=0.7u
X833 VSS a_17684_180275# a_17684_180275# VSS nfet_06v0 ad=13p pd=50.52u as=13p ps=50.52u w=50u l=0.7u
X834 a_17684_168611# ESD_RAIL ESD_RAIL VSS nfet_06v0 ad=13p pd=50.52u as=13p ps=50.52u w=50u l=0.7u
X835 a_17684_180275# a_17684_180275# VSS VSS nfet_06v0 ad=13p pd=50.52u as=13p ps=50.52u w=50u l=0.7u
X836 VSS a_17684_180275# a_17684_180275# VSS nfet_06v0 ad=13p pd=50.52u as=13p ps=50.52u w=50u l=0.7u
X837 ESD_RAIL ESD_RAIL a_17684_168611# VSS nfet_06v0 ad=13p pd=50.52u as=13p ps=50.52u w=50u l=0.7u
X838 VSS a_17684_180275# a_17684_180275# VSS nfet_06v0 ad=13p pd=50.52u as=13p ps=50.52u w=50u l=0.7u
X839 VSS a_17684_180275# a_17684_180275# VSS nfet_06v0 ad=13p pd=50.52u as=13p ps=50.52u w=50u l=0.7u
X840 a_17684_180275# a_17684_168611# a_17684_168611# VSS nfet_06v0 ad=13p pd=50.52u as=13p ps=50.52u w=50u l=0.7u
X841 a_17684_180275# a_17684_180275# VSS VSS nfet_06v0 ad=13p pd=50.52u as=13p ps=50.52u w=50u l=0.7u
X842 a_17684_168611# ESD_RAIL ESD_RAIL VSS nfet_06v0 ad=13p pd=50.52u as=13p ps=50.52u w=50u l=0.7u
X843 a_17684_180275# a_17684_180275# VSS VSS nfet_06v0 ad=13p pd=50.52u as=13p ps=50.52u w=50u l=0.7u
X844 ESD_RAIL ESD_RAIL a_17684_168611# VSS nfet_06v0 ad=13p pd=50.52u as=13p ps=50.52u w=50u l=0.7u
X845 VSS a_17684_180275# a_17684_180275# VSS nfet_06v0 ad=13p pd=50.52u as=13p ps=50.52u w=50u l=0.7u
X846 a_17684_180275# a_17684_168611# a_17684_168611# VSS nfet_06v0 ad=13p pd=50.52u as=13p ps=50.52u w=50u l=0.7u
X847 ESD_RAIL a_18245_110628# VSS VSS nfet_06v0 ad=13p pd=50.52u as=13p ps=50.52u w=50u l=0.7u
X848 ESD_RAIL ESD_RAIL a_17684_168611# VSS nfet_06v0 ad=13p pd=50.52u as=13p ps=50.52u w=50u l=0.7u
X849 VSS a_17684_180275# a_17684_180275# VSS nfet_06v0 ad=13p pd=50.52u as=13p ps=50.52u w=50u l=0.7u
X850 ESD_RAIL ATB_ESD_RAIL VSS ppolyf_u_1k_6p0 r_width=1u r_length=0.47474m
X851 ESD_RAIL a_18245_110628# VSS VSS nfet_06v0 ad=13p pd=50.52u as=13p ps=50.52u w=50u l=0.7u
X852 a_17684_180275# a_17684_180275# VSS VSS nfet_06v0 ad=13p pd=50.52u as=13p ps=50.52u w=50u l=0.7u
D17 VSS ESD_RAIL diode_nd2ps_06v0 pj=82u area=40p
X853 a_17684_168611# ESD_RAIL ESD_RAIL VSS nfet_06v0 ad=13p pd=50.52u as=13p ps=50.52u w=50u l=0.7u
X854 a_17684_168611# ESD_RAIL ESD_RAIL VSS nfet_06v0 ad=13p pd=50.52u as=13p ps=50.52u w=50u l=0.7u
X855 ESD_RAIL ESD_RAIL a_17684_168611# VSS nfet_06v0 ad=13p pd=50.52u as=13p ps=50.52u w=50u l=0.7u
X856 ESD_RAIL VSS cap_mim_2f0_m4m5_noshield c_width=31.6u c_length=31.6u
X857 ESD_RAIL ESD_RAIL a_17684_168611# VSS nfet_06v0 ad=13p pd=50.52u as=13p ps=50.52u w=50u l=0.7u
X858 a_17684_168611# ESD_RAIL ESD_RAIL VSS nfet_06v0 ad=13p pd=50.52u as=13p ps=50.52u w=50u l=0.7u
D18 VSS ESD_RAIL diode_nd2ps_06v0 pj=82u area=40p
X859 a_17684_168611# ESD_RAIL ESD_RAIL VSS nfet_06v0 ad=13p pd=50.52u as=13p ps=50.52u w=50u l=0.7u
X860 ESD_RAIL ESD_RAIL a_17684_168611# VSS nfet_06v0 ad=13p pd=50.52u as=13p ps=50.52u w=50u l=0.7u
X861 VSS a_17684_180275# a_17684_180275# VSS nfet_06v0 ad=13p pd=50.52u as=13p ps=50.52u w=50u l=0.7u
X862 a_17684_180275# a_17684_168611# a_17684_168611# VSS nfet_06v0 ad=13p pd=50.52u as=13p ps=50.52u w=50u l=0.7u
X863 a_17684_168611# ESD_RAIL ESD_RAIL VSS nfet_06v0 ad=13p pd=50.52u as=13p ps=50.52u w=50u l=0.7u
X864 a_17684_168611# a_17684_168611# a_17684_180275# VSS nfet_06v0 ad=13p pd=50.52u as=13p ps=50.52u w=50u l=0.7u
X865 a_17684_180275# a_17684_180275# VSS VSS nfet_06v0 ad=13p pd=50.52u as=13p ps=50.52u w=50u l=0.7u
X866 a_17684_168611# a_17684_168611# a_17684_180275# VSS nfet_06v0 ad=13p pd=50.52u as=13p ps=50.52u w=50u l=0.7u
X867 BIAS_P_2 BIAS_P_3 VSS ppolyf_u_1k r_width=1u r_length=12.5u
X868 VSS a_17684_180275# a_17684_180275# VSS nfet_06v0 ad=13p pd=50.52u as=13p ps=50.52u w=50u l=0.7u
X869 PAD_N BIAS_N_0 VSS ppolyf_u_1k r_width=1u r_length=12.5u
X870 a_17684_168611# ESD_RAIL ESD_RAIL VSS nfet_06v0 ad=13p pd=50.52u as=13p ps=50.52u w=50u l=0.7u
X871 ESD_RAIL ESD_RAIL a_17684_168611# VSS nfet_06v0 ad=13p pd=50.52u as=13p ps=50.52u w=50u l=0.7u
X872 a_17684_180275# a_17684_168611# a_17684_168611# VSS nfet_06v0 ad=13p pd=50.52u as=13p ps=50.52u w=50u l=0.7u
X873 a_17684_168611# ESD_RAIL ESD_RAIL VSS nfet_06v0 ad=13p pd=50.52u as=13p ps=50.52u w=50u l=0.7u
X874 a_17684_180275# a_17684_180275# VSS VSS nfet_06v0 ad=13p pd=50.52u as=13p ps=50.52u w=50u l=0.7u
X875 a_17684_168611# a_17684_168611# a_17684_180275# VSS nfet_06v0 ad=13p pd=50.52u as=13p ps=50.52u w=50u l=0.7u
D19 PAD_N ESD_RAIL diode_pd2nw_06v0 pj=51.8u area=22.5p
X876 a_17684_168611# ESD_RAIL ESD_RAIL VSS nfet_06v0 ad=13p pd=50.52u as=13p ps=50.52u w=50u l=0.7u
C0 BIAS_N_5 BIAS_N_4 10.1454f
C1 a_17005_154065# ESD_RAIL 0.57348f
C2 PAD_P ESD_RAIL 24.1165f
C3 BIAS_N_2 BIAS_P_6 0.10821f
C4 BIAS_N_2 VCM 0.09632f
C5 BIAS_N_1 BIAS_N_5 0.00763f
C6 BIAS_N_0 BIAS_P_5 0.09834f
C7 a_29878_153225# a_29878_153785# 0.0346f
C8 BIAS_N_3 BIAS_N_0 0.1108f
C9 a_17005_151825# m2_18279_144800# 0
C10 PAD_P BIAS_P_0 1.17935f
C11 PAD_P PAD_N 17.2314f
C12 BIAS_N_3 BIAS_P_5 0.12613f
C13 BIAS_P_4 BIAS_P_1 0.0868f
C14 m2_18279_144800# a_17005_151545# 0.05457f
C15 BIAS_P_6 BIAS_N_5 0.00763f
C16 VCM BIAS_N_5 0.05299f
C17 BIAS_P_0 BIAS_P_2 0.10887f
C18 BIAS_P_2 PAD_N 0.02185f
C19 BIAS_N_1 BIAS_N_4 0.0868f
C20 a_17005_151825# a_17005_151545# 0.03725f
C21 ESD_RAIL m2_18279_144800# 5.47988f
C22 a_19813_137064# a_17005_151545# 2.2693f
C23 a_17005_152385# m2_18279_144800# 0
C24 ESD_RAIL a_17005_151825# 0.53823f
C25 ESD_RAIL a_19813_137064# 4.89902f
C26 ESD_RAIL a_17005_151545# 96.5489f
C27 a_17005_152945# a_17005_153505# 0.0346f
C28 PAD_P BIAS_P_3 0.11063f
C29 a_17005_151825# a_17005_152385# 0.0346f
C30 BIAS_N_6 BIAS_N_5 0.49988f
C31 BIAS_P_6 BIAS_P_4 0
C32 BIAS_N_2 BIAS_N_0 0.10764f
C33 BIAS_P_6 BIAS_N_4 0.08663f
C34 a_17005_152385# a_17005_151545# 0
C35 BIAS_P_2 BIAS_P_3 6.55301f
C36 VCM BIAS_N_4 0.09532f
C37 ESD_RAIL a_29878_154345# 0.5677f
C38 a_17005_154065# a_17005_153505# 0.0346f
C39 BIAS_N_2 BIAS_P_5 0.12169f
C40 BIAS_N_1 BIAS_P_6 0.10963f
C41 BIAS_N_1 VCM 0.09846f
C42 PAD_P BIAS_N_0 0.00329f
C43 ESD_RAIL a_17005_152385# 0.53823f
C44 BIAS_P_0 BIAS_P_4 0.08663f
C45 PAD_N BIAS_P_4 0.01119f
C46 BIAS_P_0 BIAS_P_1 3.45373f
C47 BIAS_P_2 BIAS_N_0 0.00629f
C48 PAD_N BIAS_P_1 0.03082f
C49 PAD_P BIAS_P_5 0.00763f
C50 BIAS_N_2 BIAS_N_3 7.09482f
C51 a_29878_152105# a_29878_151545# 0.0346f
C52 ESD_RAIL a_29878_152665# 0.53916f
C53 BIAS_P_2 BIAS_P_5 0.0078f
C54 a_20789_137064# a_19813_137064# 2.94235f
C55 a_20789_137064# a_17005_151545# 0.02879f
C56 BIAS_N_0 BIAS_N_5 0.00763f
C57 BIAS_N_6 BIAS_N_4 0
C58 ESD_RAIL PAD_N 22.0614f
C59 BIAS_P_6 VCM 1.0635f
C60 BIAS_P_5 BIAS_N_5 0.01159f
C61 a_20789_137064# ESD_RAIL 13.9519f
C62 BIAS_P_3 BIAS_P_4 8.08283f
C63 BIAS_P_3 BIAS_P_1 0.1116f
C64 BIAS_N_3 BIAS_N_5 0.00855f
C65 BIAS_P_6 PAD_N 0
C66 a_17005_153505# m2_18279_144800# 0
C67 BIAS_N_0 BIAS_N_4 0.08663f
C68 BIAS_N_0 BIAS_P_1 0.05213f
C69 BIAS_P_0 PAD_N 0.15393f
C70 a_18245_110628# a_19813_137064# 0.00994f
C71 BIAS_N_6 VCM 1.0668f
C72 a_18245_110628# a_17005_151545# 0.0135f
C73 BIAS_P_4 BIAS_P_5 9.61464f
C74 BIAS_P_5 BIAS_N_4 0.11554f
C75 BIAS_N_1 BIAS_N_0 3.99133f
C76 BIAS_P_5 BIAS_P_1 0.00763f
C77 a_29878_153785# a_29878_154345# 0.0346f
C78 a_29878_153785# ESD_RAIL 0.53942f
C79 ESD_RAIL a_17005_153505# 0.53842f
C80 BIAS_N_1 BIAS_P_5 0.1199f
C81 ESD_RAIL a_18245_110628# 0.24367p
C82 BIAS_N_3 BIAS_N_4 8.62475f
C83 BIAS_N_1 BIAS_N_3 0.1116f
C84 PAD_P BIAS_P_2 0.1072f
C85 BIAS_N_2 BIAS_N_5 0.0078f
C86 BIAS_P_0 BIAS_P_3 0.11087f
C87 PAD_N BIAS_P_3 0.01254f
C88 BIAS_P_6 BIAS_N_0 0.19399f
C89 BIAS_N_0 VCM 0.21208f
C90 a_29878_153225# ESD_RAIL 0.53916f
C91 BIAS_P_6 BIAS_P_5 0.56443f
C92 BIAS_P_5 VCM 0.0015f
C93 BIAS_P_0 BIAS_N_0 0.20954f
C94 ESD_RAIL a_29878_152105# 0.53942f
C95 BIAS_N_0 PAD_N 0.444f
C96 a_17005_152945# m2_18279_144800# 0
C97 a_20789_137064# a_18245_110628# 10.1844f
C98 a_17684_180275# a_17684_168611# 1.22075p
C99 BIAS_P_6 BIAS_N_3 0.11069f
C100 BIAS_P_0 BIAS_P_5 0.00763f
C101 BIAS_N_3 VCM 0.09539f
C102 PAD_N BIAS_P_5 0.00759f
C103 BIAS_N_2 BIAS_N_4 0.08755f
C104 a_29878_153225# a_29878_152665# 0.0346f
C105 a_17005_154065# m2_18279_144800# 0
C106 a_17005_152945# a_17005_151545# 0
C107 ESD_RAIL a_17684_168611# 1.21921p
C108 a_29878_152105# a_29878_152665# 0.0346f
C109 BIAS_N_1 BIAS_N_2 5.54281f
C110 BIAS_N_6 BIAS_P_5 0
C111 PAD_P BIAS_P_4 0.08663f
C112 PAD_P BIAS_P_1 0.10649f
C113 ESD_RAIL a_29878_151545# 0.56772f
C114 ESD_RAIL a_17005_152945# 0.53823f
C115 BIAS_P_2 BIAS_P_4 0.08755f
C116 BIAS_P_2 BIAS_P_1 5.0011f
C117 a_17005_152945# a_17005_152385# 0.0346f
C118 BIAS_P_3 BIAS_P_5 0.00855f
C119 VCM VSS 11.8923f
C120 ATB_ESD_RAIL VSS 0.86326f
C121 PAD_P VSS 0.27377p
C122 PAD_N VSS 0.27517p
C123 ESD_RAIL VSS 1841.055664f
C124 m2_18279_144800# VSS 7.46506f $ **FLOATING
C125 BIAS_P_4 VSS 16.8847f
C126 BIAS_P_3 VSS 13.9105f
C127 BIAS_P_2 VSS 11.0489f
C128 BIAS_P_1 VSS 8.17942f
C129 BIAS_P_0 VSS 5.61856f
C130 BIAS_N_4 VSS 17.015f
C131 BIAS_N_3 VSS 14.0185f
C132 BIAS_N_2 VSS 11.1732f
C133 BIAS_N_1 VSS 8.34242f
C134 BIAS_N_0 VSS 6.74563f
C135 BIAS_P_6 VSS 4.19511f
C136 BIAS_P_5 VSS 14.0052f
C137 BIAS_N_6 VSS 4.29492f
C138 BIAS_N_5 VSS 14.0325f
C139 a_18245_110628# VSS 0.24984p
C140 a_20789_137064# VSS 12.0947f
C141 a_19813_137064# VSS 5.60447f
C142 a_17005_151545# VSS 0.10822p
C143 a_29878_151545# VSS 0.07835f
C144 a_17005_151825# VSS 0.07377f
C145 a_29878_152105# VSS 0.07394f
C146 a_17005_152385# VSS 0.07377f
C147 a_29878_152665# VSS 0.07394f
C148 a_17005_152945# VSS 0.07377f
C149 a_29878_153225# VSS 0.07394f
C150 a_17005_153505# VSS 0.07377f
C151 a_29878_153785# VSS 0.07394f
C152 a_17005_154065# VSS 0.07377f
C153 a_29878_154345# VSS 0.07838f
C154 a_17684_168611# VSS 0.28621p
C155 a_17684_180275# VSS 1.50941p
DWELL_ARRAY VSS ESD_RAIL diode_nw2ps_06v0 area=569.4528p pj=470.72u
.ends

.lib /home/ubuntu/svalbard/scratch/transceiver-pad-pdk/ngspice/sm141064.ngspice diode_typical
.lib /home/ubuntu/svalbard/scratch/transceiver-pad-pdk/ngspice/sm141064.ngspice mimcap_typical
