.subckt tx_protected_pad PAD_P PAD_N VSS VCM DVDD
XPHYSICAL PAD_P PAD_N VSS VCM DVDD combined_flat
.ends tx_protected_pad
* NGSPICE file created from combined_flat.ext - technology: gf180mcuD

.subckt combined_flat PAD_P PAD_N VSS VCM DVDD
D0 PAD_N DVDD diode_pd2nw_06v0 pj=51.8u area=22.5p
D1 VSS PAD_N diode_nd2ps_06v0 pj=51.8u area=22.5p
X0 BIAS_N_5 BIAS_N_6 VSS ppolyf_u_1k r_width=1u r_length=12.5u
D2 PAD_P DVDD diode_pd2nw_06v0 pj=51.8u area=22.5p
D3 PAD_N DVDD diode_pd2nw_06v0 pj=51.8u area=22.5p
D4 VSS PAD_P diode_nd2ps_06v0 pj=51.8u area=22.5p
D5 VSS PAD_N diode_nd2ps_06v0 pj=51.8u area=22.5p
D6 PAD_P DVDD diode_pd2nw_06v0 pj=51.8u area=22.5p
X1 BIAS_N_2 BIAS_N_3 VSS ppolyf_u_1k r_width=1u r_length=12.5u
D7 PAD_P DVDD diode_pd2nw_06v0 pj=51.8u area=22.5p
D8 PAD_N DVDD diode_pd2nw_06v0 pj=51.8u area=22.5p
D9 VSS PAD_P diode_nd2ps_06v0 pj=51.8u area=22.5p
D10 VSS PAD_P diode_nd2ps_06v0 pj=51.8u area=22.5p
X2 BIAS_P_3 BIAS_P_4 VSS ppolyf_u_1k r_width=1u r_length=12.5u
X3 BIAS_P_2 BIAS_P_3 VSS ppolyf_u_1k r_width=1u r_length=12.5u
X4 BIAS_N_4 BIAS_N_5 VSS ppolyf_u_1k r_width=1u r_length=12.5u
D11 PAD_P DVDD diode_pd2nw_06v0 pj=51.8u area=22.5p
D12 VSS PAD_N diode_nd2ps_06v0 pj=51.8u area=22.5p
D13 PAD_P DVDD diode_pd2nw_06v0 pj=51.8u area=22.5p
D14 PAD_N DVDD diode_pd2nw_06v0 pj=51.8u area=22.5p
X5 BIAS_P_6 VCM VSS ppolyf_u_1k r_width=1u r_length=12.5u
D15 PAD_N DVDD diode_pd2nw_06v0 pj=51.8u area=22.5p
X6 BIAS_P_0 BIAS_P_1 VSS ppolyf_u_1k r_width=1u r_length=12.5u
X7 BIAS_P_5 BIAS_P_6 VSS ppolyf_u_1k r_width=1u r_length=12.5u
D16 PAD_N DVDD diode_pd2nw_06v0 pj=51.8u area=22.5p
X8 BIAS_N_1 BIAS_N_2 VSS ppolyf_u_1k r_width=1u r_length=12.5u
D17 PAD_P DVDD diode_pd2nw_06v0 pj=51.8u area=22.5p
D18 VSS PAD_N diode_nd2ps_06v0 pj=51.8u area=22.5p
X9 BIAS_N_3 BIAS_N_4 VSS ppolyf_u_1k r_width=1u r_length=12.5u
X10 BIAS_P_1 BIAS_P_2 VSS ppolyf_u_1k r_width=1u r_length=12.5u
X11 PAD_P BIAS_P_0 VSS ppolyf_u_1k r_width=1u r_length=12.5u
D19 PAD_P DVDD diode_pd2nw_06v0 pj=51.8u area=22.5p
D20 VSS PAD_P diode_nd2ps_06v0 pj=51.8u area=22.5p
D21 PAD_P DVDD diode_pd2nw_06v0 pj=51.8u area=22.5p
D22 PAD_N DVDD diode_pd2nw_06v0 pj=51.8u area=22.5p
X12 BIAS_N_6 VCM VSS ppolyf_u_1k r_width=1u r_length=12.5u
D23 PAD_N DVDD diode_pd2nw_06v0 pj=51.8u area=22.5p
D24 VSS PAD_P diode_nd2ps_06v0 pj=51.8u area=22.5p
D25 VSS PAD_N diode_nd2ps_06v0 pj=51.8u area=22.5p
X13 BIAS_N_0 BIAS_N_1 VSS ppolyf_u_1k r_width=1u r_length=12.5u
X14 BIAS_P_4 BIAS_P_5 VSS ppolyf_u_1k r_width=1u r_length=12.5u
X15 PAD_N BIAS_N_0 VSS ppolyf_u_1k r_width=1u r_length=12.5u
C0 PAD_P BIAS_P_3 0.40676f
C1 BIAS_P_2 PAD_N 0.26224f
C2 BIAS_P_2 BIAS_P_4 0.06278f
C3 BIAS_N_6 BIAS_N_3 0.13175f
C4 BIAS_N_6 BIAS_N_5 3.55176f
C5 PAD_P VCM 47.7512f
C6 DVDD PAD_P 60.9948f
C7 VCM BIAS_P_5 0.07484f
C8 PAD_N BIAS_P_6 0.93458f
C9 BIAS_P_0 BIAS_N_0 0.20954f
C10 BIAS_P_4 BIAS_P_6 0.00228f
C11 BIAS_P_0 PAD_N 0.65412f
C12 BIAS_N_0 PAD_N 0.46444f
C13 BIAS_N_1 BIAS_N_0 0.85489f
C14 VCM BIAS_N_4 0.05163f
C15 BIAS_N_1 PAD_N 0.1947f
C16 BIAS_P_2 BIAS_P_1 0.27824f
C17 BIAS_P_4 BIAS_N_0 0.0253f
C18 BIAS_P_4 PAD_N 1.00207f
C19 BIAS_P_4 BIAS_N_1 0.00103f
C20 BIAS_N_0 BIAS_N_2 0.11843f
C21 PAD_N BIAS_N_2 0.41491f
C22 BIAS_N_1 BIAS_N_2 2.38477f
C23 BIAS_N_6 PAD_P 0.23379f
C24 BIAS_N_0 BIAS_N_3 0.09904f
C25 BIAS_N_3 PAD_N 0.2554f
C26 BIAS_N_1 BIAS_N_3 0.0653f
C27 BIAS_P_2 PAD_P 0.23889f
C28 BIAS_N_6 BIAS_N_4 0.0653f
C29 PAD_N BIAS_N_5 0.41491f
C30 BIAS_N_3 BIAS_N_2 3.78393f
C31 BIAS_P_0 BIAS_P_1 3.39678f
C32 BIAS_N_0 BIAS_P_1 0.32139f
C33 PAD_N BIAS_P_1 0.70669f
C34 BIAS_P_4 BIAS_P_1 0.034f
C35 BIAS_P_2 BIAS_P_3 1.71751f
C36 PAD_P BIAS_P_6 0.5037f
C37 BIAS_N_3 BIAS_N_5 0.11974f
C38 BIAS_P_5 BIAS_P_6 1.46515f
C39 BIAS_N_6 VCM 0.17957f
C40 PAD_P BIAS_P_0 1.11529f
C41 PAD_P PAD_N 57.5165f
C42 PAD_P BIAS_N_1 0.23321f
C43 PAD_N BIAS_P_5 0.36873f
C44 BIAS_P_4 PAD_P 0.23948f
C45 PAD_P BIAS_N_2 0.39538f
C46 BIAS_P_4 BIAS_P_5 0.47572f
C47 BIAS_N_0 BIAS_N_4 0.00103f
C48 PAD_N BIAS_N_4 0.1947f
C49 BIAS_P_3 PAD_N 0.50239f
C50 PAD_P BIAS_N_3 0.23379f
C51 PAD_P BIAS_N_5 0.39538f
C52 BIAS_P_4 BIAS_P_3 3.16384f
C53 VCM BIAS_P_6 1.99081f
C54 PAD_P BIAS_P_1 0.30166f
C55 BIAS_N_3 BIAS_N_4 0.6241f
C56 BIAS_P_5 BIAS_P_1 0
C57 VCM PAD_N 0.2522f
C58 BIAS_N_1 VCM 0.05163f
C59 BIAS_N_4 BIAS_N_5 2.15441f
C60 DVDD PAD_N 60.9948f
C61 VCM BIAS_N_2 0.0755f
C62 BIAS_P_3 BIAS_P_1 0.00832f
C63 PAD_P BIAS_P_5 0.24067f
C64 VCM BIAS_N_3 0.04195f
C65 BIAS_N_6 PAD_N 0.2563f
C66 VCM BIAS_N_5 0.0755f
C67 PAD_P BIAS_N_4 0.23321f
C68 PAD_P VSS 0.26252p
C69 PAD_N VSS 0.29391p
C70 VCM VSS 55.8729f
C71 DVDD VSS 0.29085p
C72 BIAS_P_0 VSS 4.67095f
C73 BIAS_P_3 VSS 4.33542f
C74 BIAS_P_2 VSS 4.03008f
C75 BIAS_P_1 VSS 6.04814f
C76 BIAS_P_6 VSS 4.5349f
C77 BIAS_P_5 VSS 4.04847f
C78 BIAS_P_4 VSS 6.30889f
C79 BIAS_N_2 VSS 4.52731f
C80 BIAS_N_1 VSS 4.29251f
C81 BIAS_N_0 VSS 7.62753f
C82 BIAS_N_5 VSS 4.46932f
C83 BIAS_N_4 VSS 4.23742f
C84 BIAS_N_3 VSS 6.90398f
C85 BIAS_N_6 VSS 6.72764f
.ends

.lib /home/ubuntu/svalbard/scratch/transceiver-pad-pdk/ngspice/sm141064.ngspice diode_typical
.lib /home/ubuntu/svalbard/scratch/transceiver-pad-pdk/ngspice/sm141064.ngspice mimcap_typical
