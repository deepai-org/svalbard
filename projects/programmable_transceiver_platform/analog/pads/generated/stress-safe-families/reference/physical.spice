.subckt tx_protected_pad PAD_P PAD_N VSS VCM ATB_ESD_RAIL
XPHYSICAL PAD_P PAD_N VSS VCM ESD_RAIL ATB_ESD_RAIL combined_flat
.ends tx_protected_pad
* NGSPICE file created from combined_flat.ext - technology: gf180mcuD

.subckt combined_flat PAD_P PAD_N VSS VCM ESD_RAIL ATB_ESD_RAIL
X0 a_17764_160995# a_17764_160995# VSS VSS nfet_06v0 ad=13.936p pd=54.12u as=23.584p ps=0.10808m w=53.6u l=0.7u
X1 VSS a_17764_160995# a_17764_160995# VSS nfet_06v0 ad=13.936p pd=54.12u as=13.936p ps=54.12u w=53.6u l=0.7u
X2 a_17764_148611# a_17764_148611# a_17764_160995# VSS nfet_06v0 ad=13.936p pd=54.12u as=13.936p ps=54.12u w=53.6u l=0.7u
X3 a_17005_132385# a_29878_132665# ESD_RAIL ppolyf_u r_width=0.8u r_length=63.855u
X4 VSS a_17764_160995# a_17764_160995# VSS nfet_06v0 ad=13.936p pd=54.12u as=13.936p ps=54.12u w=53.6u l=0.7u
X5 a_17764_148611# a_17764_148611# a_17764_160995# VSS nfet_06v0 ad=13.936p pd=54.12u as=13.936p ps=54.12u w=53.6u l=0.7u
X6 a_17764_148611# a_17764_148611# a_17764_160995# VSS nfet_06v0 ad=13.936p pd=54.12u as=13.936p ps=54.12u w=53.6u l=0.7u
X7 a_17764_160995# a_17764_160995# VSS VSS nfet_06v0 ad=13.936p pd=54.12u as=13.936p ps=54.12u w=53.6u l=0.7u
X8 a_17764_160995# a_17764_148611# a_17764_148611# VSS nfet_06v0 ad=13.936p pd=54.12u as=13.936p ps=54.12u w=53.6u l=0.7u
X9 VSS a_20789_117064# a_18245_90628# VSS nfet_06v0 ad=2.2p pd=10.88u as=1.3p ps=5.52u w=5u l=0.7u
X10 a_18245_90628# a_20789_117064# ESD_RAIL ESD_RAIL pfet_06v0 ad=1.3p pd=5.52u as=1.3p ps=5.52u w=5u l=0.7u
X11 ESD_RAIL ESD_RAIL a_17764_148611# VSS nfet_06v0 ad=13.936p pd=54.12u as=13.936p ps=54.12u w=53.6u l=0.7u
X12 VSS a_17764_160995# a_17764_160995# VSS nfet_06v0 ad=13.936p pd=54.12u as=13.936p ps=54.12u w=53.6u l=0.7u
X13 VSS a_17764_160995# a_17764_160995# VSS nfet_06v0 ad=13.936p pd=54.12u as=13.936p ps=54.12u w=53.6u l=0.7u
X14 a_17764_148611# a_17764_148611# a_17764_160995# VSS nfet_06v0 ad=13.936p pd=54.12u as=23.584p ps=0.10808m w=53.6u l=0.7u
X15 VSS a_18245_90628# ESD_RAIL VSS nfet_06v0 ad=13p pd=50.52u as=13p ps=50.52u w=50u l=0.7u
X16 ESD_RAIL a_20789_117064# a_18245_90628# ESD_RAIL pfet_06v0 ad=1.3p pd=5.52u as=1.3p ps=5.52u w=5u l=0.7u
X17 a_17764_148611# ESD_RAIL ESD_RAIL VSS nfet_06v0 ad=13.936p pd=54.12u as=13.936p ps=54.12u w=53.6u l=0.7u
X18 a_17764_148611# ESD_RAIL ESD_RAIL VSS nfet_06v0 ad=13.936p pd=54.12u as=13.936p ps=54.12u w=53.6u l=0.7u
X19 a_17764_148611# a_17764_148611# a_17764_160995# VSS nfet_06v0 ad=13.936p pd=54.12u as=13.936p ps=54.12u w=53.6u l=0.7u
X20 VSS a_18245_90628# ESD_RAIL VSS nfet_06v0 ad=13p pd=50.52u as=13p ps=50.52u w=50u l=0.7u
X21 ESD_RAIL ESD_RAIL a_17764_148611# VSS nfet_06v0 ad=13.936p pd=54.12u as=13.936p ps=54.12u w=53.6u l=0.7u
X22 VSS a_17764_160995# a_17764_160995# VSS nfet_06v0 ad=13.936p pd=54.12u as=13.936p ps=54.12u w=53.6u l=0.7u
X23 a_17764_160995# a_17764_160995# VSS VSS nfet_06v0 ad=13.936p pd=54.12u as=13.936p ps=54.12u w=53.6u l=0.7u
X24 a_17764_148611# a_17764_148611# a_17764_160995# VSS nfet_06v0 ad=13.936p pd=54.12u as=13.936p ps=54.12u w=53.6u l=0.7u
X25 a_17764_160995# a_17764_148611# a_17764_148611# VSS nfet_06v0 ad=13.936p pd=54.12u as=13.936p ps=54.12u w=53.6u l=0.7u
X26 ESD_RAIL ESD_RAIL a_17764_148611# VSS nfet_06v0 ad=13.936p pd=54.12u as=13.936p ps=54.12u w=53.6u l=0.7u
X27 a_17764_160995# a_17764_148611# a_17764_148611# VSS nfet_06v0 ad=13.936p pd=54.12u as=13.936p ps=54.12u w=53.6u l=0.7u
X28 ESD_RAIL ESD_RAIL a_17764_148611# VSS nfet_06v0 ad=13.936p pd=54.12u as=13.936p ps=54.12u w=53.6u l=0.7u
X29 VSS a_17764_160995# a_17764_160995# VSS nfet_06v0 ad=13.936p pd=54.12u as=13.936p ps=54.12u w=53.6u l=0.7u
X30 ESD_RAIL a_18245_90628# VSS VSS nfet_06v0 ad=13p pd=50.52u as=13p ps=50.52u w=50u l=0.7u
X31 a_18245_90628# a_20789_117064# VSS VSS nfet_06v0 ad=1.3p pd=5.52u as=1.3p ps=5.52u w=5u l=0.7u
X32 ESD_RAIL a_20789_117064# a_18245_90628# ESD_RAIL pfet_06v0 ad=1.3p pd=5.52u as=1.3p ps=5.52u w=5u l=0.7u
X33 a_17764_148611# a_17764_148611# a_17764_160995# VSS nfet_06v0 ad=13.936p pd=54.12u as=13.936p ps=54.12u w=53.6u l=0.7u
X34 a_17764_148611# a_17764_148611# a_17764_160995# VSS nfet_06v0 ad=13.936p pd=54.12u as=13.936p ps=54.12u w=53.6u l=0.7u
X35 a_18245_90628# a_20789_117064# ESD_RAIL ESD_RAIL pfet_06v0 ad=1.3p pd=5.52u as=2.2p ps=10.88u w=5u l=0.7u
X36 ESD_RAIL ESD_RAIL a_17764_148611# VSS nfet_06v0 ad=13.936p pd=54.12u as=13.936p ps=54.12u w=53.6u l=0.7u
X37 ESD_RAIL ESD_RAIL a_17764_148611# VSS nfet_06v0 ad=13.936p pd=54.12u as=13.936p ps=54.12u w=53.6u l=0.7u
X38 a_17764_160995# a_17764_160995# VSS VSS nfet_06v0 ad=13.936p pd=54.12u as=13.936p ps=54.12u w=53.6u l=0.7u
X39 a_17764_160995# a_17764_160995# VSS VSS nfet_06v0 ad=13.936p pd=54.12u as=13.936p ps=54.12u w=53.6u l=0.7u
X40 a_19813_117064# a_17005_131545# VSS VSS nfet_06v0 ad=2.2p pd=10.88u as=2.2p ps=10.88u w=5u l=0.7u
X41 a_17764_148611# ESD_RAIL ESD_RAIL VSS nfet_06v0 ad=23.584p pd=0.10808m as=13.936p ps=54.12u w=53.6u l=0.7u
X42 ESD_RAIL ESD_RAIL a_17764_148611# VSS nfet_06v0 ad=13.936p pd=54.12u as=13.936p ps=54.12u w=53.6u l=0.7u
X43 a_17764_160995# a_17764_160995# VSS VSS nfet_06v0 ad=13.936p pd=54.12u as=13.936p ps=54.12u w=53.6u l=0.7u
X44 a_17764_160995# a_17764_148611# a_17764_148611# VSS nfet_06v0 ad=13.936p pd=54.12u as=13.936p ps=54.12u w=53.6u l=0.7u
X45 a_17764_160995# a_17764_148611# a_17764_148611# VSS nfet_06v0 ad=13.936p pd=54.12u as=13.936p ps=54.12u w=53.6u l=0.7u
X46 VSS a_17764_160995# a_17764_160995# VSS nfet_06v0 ad=13.936p pd=54.12u as=13.936p ps=54.12u w=53.6u l=0.7u
D0 VSS PAD_P diode_nd2ps_06v0 pj=51.8u area=22.5p
X47 a_17005_133505# a_29878_133785# ESD_RAIL ppolyf_u r_width=0.8u r_length=63.855u
X48 a_17764_148611# ESD_RAIL ESD_RAIL VSS nfet_06v0 ad=13.936p pd=54.12u as=13.936p ps=54.12u w=53.6u l=0.7u
X49 a_17764_160995# a_17764_160995# VSS VSS nfet_06v0 ad=13.936p pd=54.12u as=13.936p ps=54.12u w=53.6u l=0.7u
X50 a_17764_160995# a_17764_148611# a_17764_148611# VSS nfet_06v0 ad=13.936p pd=54.12u as=13.936p ps=54.12u w=53.6u l=0.7u
X51 a_17764_160995# a_17764_148611# a_17764_148611# VSS nfet_06v0 ad=13.936p pd=54.12u as=13.936p ps=54.12u w=53.6u l=0.7u
X52 a_18245_90628# a_20789_117064# VSS VSS nfet_06v0 ad=1.3p pd=5.52u as=1.3p ps=5.52u w=5u l=0.7u
X53 ESD_RAIL a_18245_90628# VSS VSS nfet_06v0 ad=13p pd=50.52u as=13p ps=50.52u w=50u l=0.7u
X54 ESD_RAIL ESD_RAIL a_17764_148611# VSS nfet_06v0 ad=13.936p pd=54.12u as=13.936p ps=54.12u w=53.6u l=0.7u
X55 VSS a_19813_117064# a_20789_117064# VSS nfet_06v0 ad=1.3p pd=5.52u as=1.3p ps=5.52u w=5u l=0.7u
X56 a_18245_90628# a_20789_117064# ESD_RAIL ESD_RAIL pfet_06v0 ad=1.3p pd=5.52u as=1.3p ps=5.52u w=5u l=0.7u
X57 ESD_RAIL a_18245_90628# VSS VSS nfet_06v0 ad=13p pd=50.52u as=13p ps=50.52u w=50u l=0.7u
X58 a_17764_160995# a_17764_148611# a_17764_148611# VSS nfet_06v0 ad=13.936p pd=54.12u as=13.936p ps=54.12u w=53.6u l=0.7u
X59 VSS a_17764_160995# a_17764_160995# VSS nfet_06v0 ad=13.936p pd=54.12u as=13.936p ps=54.12u w=53.6u l=0.7u
X60 VSS a_17764_160995# a_17764_160995# VSS nfet_06v0 ad=13.936p pd=54.12u as=13.936p ps=54.12u w=53.6u l=0.7u
X61 VSS a_17764_160995# a_17764_160995# VSS nfet_06v0 ad=23.584p pd=0.10808m as=13.936p ps=54.12u w=53.6u l=0.7u
X62 a_17764_148611# a_17764_148611# a_17764_160995# VSS nfet_06v0 ad=13.936p pd=54.12u as=13.936p ps=54.12u w=53.6u l=0.7u
X63 a_17764_148611# a_17764_148611# a_17764_160995# VSS nfet_06v0 ad=13.936p pd=54.12u as=13.936p ps=54.12u w=53.6u l=0.7u
X64 a_17764_148611# ESD_RAIL ESD_RAIL VSS nfet_06v0 ad=23.584p pd=0.10808m as=13.936p ps=54.12u w=53.6u l=0.7u
X65 a_17764_148611# ESD_RAIL ESD_RAIL VSS nfet_06v0 ad=13.936p pd=54.12u as=13.936p ps=54.12u w=53.6u l=0.7u
X66 a_17005_131545# VSS cap_mim_2f0_m4m5_noshield c_width=31.6u c_length=31.6u
X67 ESD_RAIL ESD_RAIL a_17764_148611# VSS nfet_06v0 ad=13.936p pd=54.12u as=13.936p ps=54.12u w=53.6u l=0.7u
X68 a_17764_160995# a_17764_148611# a_17764_148611# VSS nfet_06v0 ad=13.936p pd=54.12u as=13.936p ps=54.12u w=53.6u l=0.7u
X69 a_17764_160995# a_17764_148611# a_17764_148611# VSS nfet_06v0 ad=13.936p pd=54.12u as=13.936p ps=54.12u w=53.6u l=0.7u
X70 a_17764_148611# a_17764_148611# a_17764_160995# VSS nfet_06v0 ad=13.936p pd=54.12u as=23.584p ps=0.10808m w=53.6u l=0.7u
X71 VSS a_18245_90628# ESD_RAIL VSS nfet_06v0 ad=13p pd=50.52u as=13p ps=50.52u w=50u l=0.7u
X72 a_17764_160995# a_17764_160995# VSS VSS nfet_06v0 ad=13.936p pd=54.12u as=13.936p ps=54.12u w=53.6u l=0.7u
X73 a_17764_148611# a_17764_148611# a_17764_160995# VSS nfet_06v0 ad=13.936p pd=54.12u as=13.936p ps=54.12u w=53.6u l=0.7u
X74 VSS a_19813_117064# a_20789_117064# VSS nfet_06v0 ad=1.3p pd=5.52u as=1.3p ps=5.52u w=5u l=0.7u
X75 a_17764_160995# a_17764_148611# a_17764_148611# VSS nfet_06v0 ad=13.936p pd=54.12u as=13.936p ps=54.12u w=53.6u l=0.7u
X76 VSS a_17764_160995# a_17764_160995# VSS nfet_06v0 ad=13.936p pd=54.12u as=13.936p ps=54.12u w=53.6u l=0.7u
X77 a_17764_160995# a_17764_148611# a_17764_148611# VSS nfet_06v0 ad=13.936p pd=54.12u as=13.936p ps=54.12u w=53.6u l=0.7u
X78 VSS a_17764_160995# a_17764_160995# VSS nfet_06v0 ad=13.936p pd=54.12u as=13.936p ps=54.12u w=53.6u l=0.7u
X79 a_17764_148611# a_17764_148611# a_17764_160995# VSS nfet_06v0 ad=13.936p pd=54.12u as=13.936p ps=54.12u w=53.6u l=0.7u
X80 a_17764_148611# ESD_RAIL ESD_RAIL VSS nfet_06v0 ad=13.936p pd=54.12u as=13.936p ps=54.12u w=53.6u l=0.7u
X81 a_17764_160995# a_17764_160995# VSS VSS nfet_06v0 ad=13.936p pd=54.12u as=13.936p ps=54.12u w=53.6u l=0.7u
X82 a_17764_160995# a_17764_148611# a_17764_148611# VSS nfet_06v0 ad=13.936p pd=54.12u as=13.936p ps=54.12u w=53.6u l=0.7u
X83 ESD_RAIL ESD_RAIL a_17764_148611# VSS nfet_06v0 ad=13.936p pd=54.12u as=13.936p ps=54.12u w=53.6u l=0.7u
X84 a_17764_160995# a_17764_160995# VSS VSS nfet_06v0 ad=13.936p pd=54.12u as=13.936p ps=54.12u w=53.6u l=0.7u
D1 PAD_P ESD_RAIL diode_pd2nw_06v0 pj=51.8u area=22.5p
D2 VSS ESD_RAIL diode_nd2ps_06v0 pj=82u area=40p
X85 VSS a_17764_160995# a_17764_160995# VSS nfet_06v0 ad=23.584p pd=0.10808m as=13.936p ps=54.12u w=53.6u l=0.7u
X86 a_17764_148611# a_17764_148611# a_17764_160995# VSS nfet_06v0 ad=13.936p pd=54.12u as=13.936p ps=54.12u w=53.6u l=0.7u
X87 a_17764_148611# a_17764_148611# a_17764_160995# VSS nfet_06v0 ad=13.936p pd=54.12u as=13.936p ps=54.12u w=53.6u l=0.7u
X88 a_17764_148611# ESD_RAIL ESD_RAIL VSS nfet_06v0 ad=23.584p pd=0.10808m as=13.936p ps=54.12u w=53.6u l=0.7u
X89 a_17764_160995# a_17764_160995# VSS VSS nfet_06v0 ad=13.936p pd=54.12u as=13.936p ps=54.12u w=53.6u l=0.7u
X90 VSS a_18245_90628# ESD_RAIL VSS nfet_06v0 ad=13p pd=50.52u as=13p ps=50.52u w=50u l=0.7u
X91 VSS a_18245_90628# ESD_RAIL VSS nfet_06v0 ad=13p pd=50.52u as=13p ps=50.52u w=50u l=0.7u
X92 a_17764_148611# a_17764_148611# a_17764_160995# VSS nfet_06v0 ad=13.936p pd=54.12u as=23.584p ps=0.10808m w=53.6u l=0.7u
X93 VSS a_18245_90628# ESD_RAIL VSS nfet_06v0 ad=13p pd=50.52u as=13p ps=50.52u w=50u l=0.7u
X94 a_17764_160995# a_17764_160995# VSS VSS nfet_06v0 ad=13.936p pd=54.12u as=13.936p ps=54.12u w=53.6u l=0.7u
X95 a_17764_160995# a_17764_148611# a_17764_148611# VSS nfet_06v0 ad=13.936p pd=54.12u as=13.936p ps=54.12u w=53.6u l=0.7u
X96 VSS a_18245_90628# ESD_RAIL VSS nfet_06v0 ad=13p pd=50.52u as=13p ps=50.52u w=50u l=0.7u
X97 a_17764_160995# a_17764_148611# a_17764_148611# VSS nfet_06v0 ad=13.936p pd=54.12u as=13.936p ps=54.12u w=53.6u l=0.7u
X98 a_17764_148611# a_17764_148611# a_17764_160995# VSS nfet_06v0 ad=13.936p pd=54.12u as=13.936p ps=54.12u w=53.6u l=0.7u
X99 VSS a_17764_160995# a_17764_160995# VSS nfet_06v0 ad=13.936p pd=54.12u as=13.936p ps=54.12u w=53.6u l=0.7u
X100 ESD_RAIL a_18245_90628# VSS VSS nfet_06v0 ad=22p pd=0.10088m as=13p ps=50.52u w=50u l=0.7u
X101 ESD_RAIL a_18245_90628# VSS VSS nfet_06v0 ad=13p pd=50.52u as=13p ps=50.52u w=50u l=0.7u
X102 a_17005_133505# a_29878_133225# ESD_RAIL ppolyf_u r_width=0.8u r_length=63.855u
X103 a_17764_160995# a_17764_160995# VSS VSS nfet_06v0 ad=13.936p pd=54.12u as=13.936p ps=54.12u w=53.6u l=0.7u
X104 a_17764_160995# a_17764_148611# a_17764_148611# VSS nfet_06v0 ad=13.936p pd=54.12u as=13.936p ps=54.12u w=53.6u l=0.7u
X105 ESD_RAIL ESD_RAIL a_17764_148611# VSS nfet_06v0 ad=13.936p pd=54.12u as=13.936p ps=54.12u w=53.6u l=0.7u
X106 a_17764_160995# a_17764_148611# a_17764_148611# VSS nfet_06v0 ad=13.936p pd=54.12u as=13.936p ps=54.12u w=53.6u l=0.7u
X107 ESD_RAIL ESD_RAIL a_17764_148611# VSS nfet_06v0 ad=13.936p pd=54.12u as=13.936p ps=54.12u w=53.6u l=0.7u
X108 VSS a_17764_160995# a_17764_160995# VSS nfet_06v0 ad=13.936p pd=54.12u as=13.936p ps=54.12u w=53.6u l=0.7u
X109 BIAS_N_5 BIAS_N_6 VSS ppolyf_u_1k r_width=1u r_length=12.5u
X110 ESD_RAIL a_18245_90628# VSS VSS nfet_06v0 ad=13p pd=50.52u as=13p ps=50.52u w=50u l=0.7u
X111 VSS a_17764_160995# a_17764_160995# VSS nfet_06v0 ad=13.936p pd=54.12u as=13.936p ps=54.12u w=53.6u l=0.7u
X112 a_17764_148611# a_17764_148611# a_17764_160995# VSS nfet_06v0 ad=13.936p pd=54.12u as=13.936p ps=54.12u w=53.6u l=0.7u
X113 VSS a_18245_90628# ESD_RAIL VSS nfet_06v0 ad=13p pd=50.52u as=13p ps=50.52u w=50u l=0.7u
X114 a_17764_160995# a_17764_148611# a_17764_148611# VSS nfet_06v0 ad=13.936p pd=54.12u as=13.936p ps=54.12u w=53.6u l=0.7u
X115 a_17764_160995# a_17764_160995# VSS VSS nfet_06v0 ad=13.936p pd=54.12u as=13.936p ps=54.12u w=53.6u l=0.7u
X116 a_17764_160995# a_17764_148611# a_17764_148611# VSS nfet_06v0 ad=13.936p pd=54.12u as=13.936p ps=54.12u w=53.6u l=0.7u
X117 a_17764_160995# a_17764_160995# VSS VSS nfet_06v0 ad=13.936p pd=54.12u as=23.584p ps=0.10808m w=53.6u l=0.7u
X118 VSS a_17764_160995# a_17764_160995# VSS nfet_06v0 ad=13.936p pd=54.12u as=13.936p ps=54.12u w=53.6u l=0.7u
X119 a_17764_148611# ESD_RAIL ESD_RAIL VSS nfet_06v0 ad=13.936p pd=54.12u as=13.936p ps=54.12u w=53.6u l=0.7u
X120 a_17764_148611# ESD_RAIL ESD_RAIL VSS nfet_06v0 ad=13.936p pd=54.12u as=13.936p ps=54.12u w=53.6u l=0.7u
X121 VSS a_17764_160995# a_17764_160995# VSS nfet_06v0 ad=13.936p pd=54.12u as=13.936p ps=54.12u w=53.6u l=0.7u
X122 a_17764_148611# a_17764_148611# a_17764_160995# VSS nfet_06v0 ad=13.936p pd=54.12u as=13.936p ps=54.12u w=53.6u l=0.7u
X123 a_17764_148611# a_17764_148611# a_17764_160995# VSS nfet_06v0 ad=13.936p pd=54.12u as=13.936p ps=54.12u w=53.6u l=0.7u
X124 a_17764_148611# a_17764_148611# a_17764_160995# VSS nfet_06v0 ad=13.936p pd=54.12u as=13.936p ps=54.12u w=53.6u l=0.7u
X125 ESD_RAIL ESD_RAIL a_17764_148611# VSS nfet_06v0 ad=13.936p pd=54.12u as=13.936p ps=54.12u w=53.6u l=0.7u
X126 a_17764_160995# a_17764_160995# VSS VSS nfet_06v0 ad=13.936p pd=54.12u as=13.936p ps=54.12u w=53.6u l=0.7u
X127 a_17764_160995# a_17764_148611# a_17764_148611# VSS nfet_06v0 ad=13.936p pd=54.12u as=13.936p ps=54.12u w=53.6u l=0.7u
X128 a_17764_148611# a_17764_148611# a_17764_160995# VSS nfet_06v0 ad=13.936p pd=54.12u as=13.936p ps=54.12u w=53.6u l=0.7u
X129 ESD_RAIL a_18245_90628# VSS VSS nfet_06v0 ad=13p pd=50.52u as=13p ps=50.52u w=50u l=0.7u
X130 a_17764_148611# ESD_RAIL ESD_RAIL VSS nfet_06v0 ad=13.936p pd=54.12u as=13.936p ps=54.12u w=53.6u l=0.7u
X131 VSS a_17764_160995# a_17764_160995# VSS nfet_06v0 ad=13.936p pd=54.12u as=13.936p ps=54.12u w=53.6u l=0.7u
X132 a_17764_148611# ESD_RAIL ESD_RAIL VSS nfet_06v0 ad=23.584p pd=0.10808m as=13.936p ps=54.12u w=53.6u l=0.7u
X133 VSS a_17764_160995# a_17764_160995# VSS nfet_06v0 ad=23.584p pd=0.10808m as=13.936p ps=54.12u w=53.6u l=0.7u
X134 ESD_RAIL a_29878_134345# ESD_RAIL ppolyf_u r_width=0.8u r_length=63.855u
X135 a_17764_160995# a_17764_160995# VSS VSS nfet_06v0 ad=13.936p pd=54.12u as=13.936p ps=54.12u w=53.6u l=0.7u
X136 a_17764_160995# a_17764_160995# VSS VSS nfet_06v0 ad=13.936p pd=54.12u as=23.584p ps=0.10808m w=53.6u l=0.7u
X137 ESD_RAIL ESD_RAIL a_17764_148611# VSS nfet_06v0 ad=13.936p pd=54.12u as=13.936p ps=54.12u w=53.6u l=0.7u
X138 ESD_RAIL ESD_RAIL a_17764_148611# VSS nfet_06v0 ad=13.936p pd=54.12u as=23.584p ps=0.10808m w=53.6u l=0.7u
X139 a_17764_160995# a_17764_148611# a_17764_148611# VSS nfet_06v0 ad=13.936p pd=54.12u as=13.936p ps=54.12u w=53.6u l=0.7u
X140 a_17764_160995# a_17764_148611# a_17764_148611# VSS nfet_06v0 ad=13.936p pd=54.12u as=13.936p ps=54.12u w=53.6u l=0.7u
X141 a_17764_160995# a_17764_148611# a_17764_148611# VSS nfet_06v0 ad=23.584p pd=0.10808m as=13.936p ps=54.12u w=53.6u l=0.7u
X142 VSS a_17764_160995# a_17764_160995# VSS nfet_06v0 ad=13.936p pd=54.12u as=13.936p ps=54.12u w=53.6u l=0.7u
X143 VSS a_17764_160995# a_17764_160995# VSS nfet_06v0 ad=13.936p pd=54.12u as=13.936p ps=54.12u w=53.6u l=0.7u
X144 a_17764_148611# ESD_RAIL ESD_RAIL VSS nfet_06v0 ad=13.936p pd=54.12u as=13.936p ps=54.12u w=53.6u l=0.7u
X145 a_17764_160995# a_17764_160995# VSS VSS nfet_06v0 ad=13.936p pd=54.12u as=13.936p ps=54.12u w=53.6u l=0.7u
X146 a_17764_148611# a_17764_148611# a_17764_160995# VSS nfet_06v0 ad=13.936p pd=54.12u as=13.936p ps=54.12u w=53.6u l=0.7u
X147 ESD_RAIL ESD_RAIL a_17764_148611# VSS nfet_06v0 ad=13.936p pd=54.12u as=13.936p ps=54.12u w=53.6u l=0.7u
X148 a_17764_160995# a_17764_160995# VSS VSS nfet_06v0 ad=13.936p pd=54.12u as=13.936p ps=54.12u w=53.6u l=0.7u
X149 VSS a_17764_160995# a_17764_160995# VSS nfet_06v0 ad=13.936p pd=54.12u as=13.936p ps=54.12u w=53.6u l=0.7u
X150 a_17764_160995# a_17764_148611# a_17764_148611# VSS nfet_06v0 ad=13.936p pd=54.12u as=13.936p ps=54.12u w=53.6u l=0.7u
X151 VSS a_18245_90628# ESD_RAIL VSS nfet_06v0 ad=13p pd=50.52u as=22p ps=0.10088m w=50u l=0.7u
X152 VSS a_17764_160995# a_17764_160995# VSS nfet_06v0 ad=13.936p pd=54.12u as=13.936p ps=54.12u w=53.6u l=0.7u
X153 a_17764_160995# a_17764_148611# a_17764_148611# VSS nfet_06v0 ad=13.936p pd=54.12u as=13.936p ps=54.12u w=53.6u l=0.7u
D3 VSS PAD_P diode_nd2ps_06v0 pj=51.8u area=22.5p
X154 VSS a_17764_160995# a_17764_160995# VSS nfet_06v0 ad=13.936p pd=54.12u as=13.936p ps=54.12u w=53.6u l=0.7u
X155 a_17764_148611# a_17764_148611# a_17764_160995# VSS nfet_06v0 ad=13.936p pd=54.12u as=13.936p ps=54.12u w=53.6u l=0.7u
X156 VSS a_18245_90628# ESD_RAIL VSS nfet_06v0 ad=13p pd=50.52u as=13p ps=50.52u w=50u l=0.7u
X157 a_17764_148611# ESD_RAIL ESD_RAIL VSS nfet_06v0 ad=13.936p pd=54.12u as=13.936p ps=54.12u w=53.6u l=0.7u
X158 a_17764_160995# a_17764_160995# VSS VSS nfet_06v0 ad=13.936p pd=54.12u as=23.584p ps=0.10808m w=53.6u l=0.7u
X159 a_17764_148611# a_17764_148611# a_17764_160995# VSS nfet_06v0 ad=13.936p pd=54.12u as=13.936p ps=54.12u w=53.6u l=0.7u
X160 ESD_RAIL a_18245_90628# VSS VSS nfet_06v0 ad=13p pd=50.52u as=13p ps=50.52u w=50u l=0.7u
X161 a_17764_148611# ESD_RAIL ESD_RAIL VSS nfet_06v0 ad=13.936p pd=54.12u as=13.936p ps=54.12u w=53.6u l=0.7u
X162 a_17764_160995# a_17764_160995# VSS VSS nfet_06v0 ad=13.936p pd=54.12u as=23.584p ps=0.10808m w=53.6u l=0.7u
X163 a_17764_160995# a_17764_160995# VSS VSS nfet_06v0 ad=13.936p pd=54.12u as=13.936p ps=54.12u w=53.6u l=0.7u
X164 ESD_RAIL ESD_RAIL a_17764_148611# VSS nfet_06v0 ad=13.936p pd=54.12u as=13.936p ps=54.12u w=53.6u l=0.7u
X165 a_17764_160995# a_17764_148611# a_17764_148611# VSS nfet_06v0 ad=23.584p pd=0.10808m as=13.936p ps=54.12u w=53.6u l=0.7u
X166 a_17764_148611# ESD_RAIL ESD_RAIL VSS nfet_06v0 ad=13.936p pd=54.12u as=13.936p ps=54.12u w=53.6u l=0.7u
X167 ESD_RAIL ESD_RAIL a_17764_148611# VSS nfet_06v0 ad=13.936p pd=54.12u as=13.936p ps=54.12u w=53.6u l=0.7u
X168 VSS a_17764_160995# a_17764_160995# VSS nfet_06v0 ad=13.936p pd=54.12u as=13.936p ps=54.12u w=53.6u l=0.7u
X169 ESD_RAIL a_18245_90628# VSS VSS nfet_06v0 ad=13p pd=50.52u as=13p ps=50.52u w=50u l=0.7u
X170 VSS a_17764_160995# a_17764_160995# VSS nfet_06v0 ad=13.936p pd=54.12u as=13.936p ps=54.12u w=53.6u l=0.7u
X171 VSS a_17764_160995# a_17764_160995# VSS nfet_06v0 ad=13.936p pd=54.12u as=13.936p ps=54.12u w=53.6u l=0.7u
X172 a_17764_148611# a_17764_148611# a_17764_160995# VSS nfet_06v0 ad=13.936p pd=54.12u as=13.936p ps=54.12u w=53.6u l=0.7u
X173 ESD_RAIL ESD_RAIL a_17764_148611# VSS nfet_06v0 ad=13.936p pd=54.12u as=13.936p ps=54.12u w=53.6u l=0.7u
X174 a_17764_160995# a_17764_160995# VSS VSS nfet_06v0 ad=13.936p pd=54.12u as=13.936p ps=54.12u w=53.6u l=0.7u
X175 VSS a_17764_160995# a_17764_160995# VSS nfet_06v0 ad=23.584p pd=0.10808m as=13.936p ps=54.12u w=53.6u l=0.7u
X176 a_17764_148611# a_17764_148611# a_17764_160995# VSS nfet_06v0 ad=13.936p pd=54.12u as=13.936p ps=54.12u w=53.6u l=0.7u
X177 ESD_RAIL ESD_RAIL a_17764_148611# VSS nfet_06v0 ad=13.936p pd=54.12u as=13.936p ps=54.12u w=53.6u l=0.7u
X178 VSS a_18245_90628# ESD_RAIL VSS nfet_06v0 ad=13p pd=50.52u as=13p ps=50.52u w=50u l=0.7u
X179 a_20789_117064# a_19813_117064# VSS VSS nfet_06v0 ad=1.3p pd=5.52u as=2.2p ps=10.88u w=5u l=0.7u
X180 ESD_RAIL ESD_RAIL a_17764_148611# VSS nfet_06v0 ad=13.936p pd=54.12u as=13.936p ps=54.12u w=53.6u l=0.7u
X181 VSS a_17764_160995# a_17764_160995# VSS nfet_06v0 ad=13.936p pd=54.12u as=13.936p ps=54.12u w=53.6u l=0.7u
X182 a_17764_160995# a_17764_160995# VSS VSS nfet_06v0 ad=13.936p pd=54.12u as=13.936p ps=54.12u w=53.6u l=0.7u
X183 a_17764_160995# a_17764_148611# a_17764_148611# VSS nfet_06v0 ad=13.936p pd=54.12u as=13.936p ps=54.12u w=53.6u l=0.7u
X184 a_17764_160995# a_17764_160995# VSS VSS nfet_06v0 ad=13.936p pd=54.12u as=23.584p ps=0.10808m w=53.6u l=0.7u
X185 a_17764_148611# a_17764_148611# a_17764_160995# VSS nfet_06v0 ad=13.936p pd=54.12u as=13.936p ps=54.12u w=53.6u l=0.7u
X186 a_17764_148611# ESD_RAIL ESD_RAIL VSS nfet_06v0 ad=13.936p pd=54.12u as=13.936p ps=54.12u w=53.6u l=0.7u
X187 a_17764_160995# a_17764_160995# VSS VSS nfet_06v0 ad=13.936p pd=54.12u as=23.584p ps=0.10808m w=53.6u l=0.7u
X188 a_17764_160995# a_17764_160995# VSS VSS nfet_06v0 ad=13.936p pd=54.12u as=13.936p ps=54.12u w=53.6u l=0.7u
X189 a_17764_160995# a_17764_148611# a_17764_148611# VSS nfet_06v0 ad=13.936p pd=54.12u as=13.936p ps=54.12u w=53.6u l=0.7u
X190 ESD_RAIL ESD_RAIL a_17764_148611# VSS nfet_06v0 ad=13.936p pd=54.12u as=13.936p ps=54.12u w=53.6u l=0.7u
X191 a_17764_160995# a_17764_148611# a_17764_148611# VSS nfet_06v0 ad=13.936p pd=54.12u as=13.936p ps=54.12u w=53.6u l=0.7u
X192 a_17764_148611# ESD_RAIL ESD_RAIL VSS nfet_06v0 ad=13.936p pd=54.12u as=13.936p ps=54.12u w=53.6u l=0.7u
X193 a_17764_148611# a_17764_148611# a_17764_160995# VSS nfet_06v0 ad=13.936p pd=54.12u as=13.936p ps=54.12u w=53.6u l=0.7u
X194 VSS a_17764_160995# a_17764_160995# VSS nfet_06v0 ad=23.584p pd=0.10808m as=13.936p ps=54.12u w=53.6u l=0.7u
X195 a_17764_148611# ESD_RAIL ESD_RAIL VSS nfet_06v0 ad=13.936p pd=54.12u as=13.936p ps=54.12u w=53.6u l=0.7u
X196 a_17764_160995# a_17764_148611# a_17764_148611# VSS nfet_06v0 ad=13.936p pd=54.12u as=13.936p ps=54.12u w=53.6u l=0.7u
X197 a_17764_148611# a_17764_148611# a_17764_160995# VSS nfet_06v0 ad=13.936p pd=54.12u as=23.584p ps=0.10808m w=53.6u l=0.7u
X198 a_17764_160995# a_17764_160995# VSS VSS nfet_06v0 ad=13.936p pd=54.12u as=13.936p ps=54.12u w=53.6u l=0.7u
X199 ESD_RAIL ESD_RAIL a_17764_148611# VSS nfet_06v0 ad=13.936p pd=54.12u as=13.936p ps=54.12u w=53.6u l=0.7u
X200 VSS a_17764_160995# a_17764_160995# VSS nfet_06v0 ad=13.936p pd=54.12u as=13.936p ps=54.12u w=53.6u l=0.7u
X201 a_17764_160995# a_17764_148611# a_17764_148611# VSS nfet_06v0 ad=13.936p pd=54.12u as=13.936p ps=54.12u w=53.6u l=0.7u
X202 a_17764_148611# ESD_RAIL ESD_RAIL VSS nfet_06v0 ad=13.936p pd=54.12u as=13.936p ps=54.12u w=53.6u l=0.7u
X203 VSS a_17764_160995# a_17764_160995# VSS nfet_06v0 ad=13.936p pd=54.12u as=13.936p ps=54.12u w=53.6u l=0.7u
D4 VSS PAD_N diode_nd2ps_06v0 pj=51.8u area=22.5p
X204 a_17764_148611# a_17764_148611# a_17764_160995# VSS nfet_06v0 ad=13.936p pd=54.12u as=13.936p ps=54.12u w=53.6u l=0.7u
X205 a_17764_160995# a_17764_160995# VSS VSS nfet_06v0 ad=13.936p pd=54.12u as=13.936p ps=54.12u w=53.6u l=0.7u
X206 a_17764_160995# a_17764_148611# a_17764_148611# VSS nfet_06v0 ad=13.936p pd=54.12u as=13.936p ps=54.12u w=53.6u l=0.7u
X207 ESD_RAIL a_18245_90628# VSS VSS nfet_06v0 ad=13p pd=50.52u as=13p ps=50.52u w=50u l=0.7u
X208 a_17764_160995# a_17764_160995# VSS VSS nfet_06v0 ad=13.936p pd=54.12u as=13.936p ps=54.12u w=53.6u l=0.7u
X209 a_18245_90628# a_20789_117064# ESD_RAIL ESD_RAIL pfet_06v0 ad=1.3p pd=5.52u as=1.3p ps=5.52u w=5u l=0.7u
X210 a_17764_160995# a_17764_148611# a_17764_148611# VSS nfet_06v0 ad=23.584p pd=0.10808m as=13.936p ps=54.12u w=53.6u l=0.7u
X211 VSS a_17764_160995# a_17764_160995# VSS nfet_06v0 ad=23.584p pd=0.10808m as=13.936p ps=54.12u w=53.6u l=0.7u
X212 a_17764_148611# a_17764_148611# a_17764_160995# VSS nfet_06v0 ad=13.936p pd=54.12u as=13.936p ps=54.12u w=53.6u l=0.7u
X213 VSS a_18245_90628# ESD_RAIL VSS nfet_06v0 ad=13p pd=50.52u as=13p ps=50.52u w=50u l=0.7u
D5 PAD_P ESD_RAIL diode_pd2nw_06v0 pj=51.8u area=22.5p
X214 a_17764_160995# a_17764_160995# VSS VSS nfet_06v0 ad=13.936p pd=54.12u as=13.936p ps=54.12u w=53.6u l=0.7u
X215 a_17764_148611# a_17764_148611# a_17764_160995# VSS nfet_06v0 ad=13.936p pd=54.12u as=23.584p ps=0.10808m w=53.6u l=0.7u
X216 ESD_RAIL ESD_RAIL a_17764_148611# VSS nfet_06v0 ad=13.936p pd=54.12u as=13.936p ps=54.12u w=53.6u l=0.7u
X217 a_17764_160995# a_17764_160995# VSS VSS nfet_06v0 ad=13.936p pd=54.12u as=13.936p ps=54.12u w=53.6u l=0.7u
X218 a_17764_160995# a_17764_160995# VSS VSS nfet_06v0 ad=13.936p pd=54.12u as=13.936p ps=54.12u w=53.6u l=0.7u
X219 a_17764_160995# a_17764_160995# VSS VSS nfet_06v0 ad=13.936p pd=54.12u as=13.936p ps=54.12u w=53.6u l=0.7u
X220 a_17764_160995# a_17764_148611# a_17764_148611# VSS nfet_06v0 ad=13.936p pd=54.12u as=13.936p ps=54.12u w=53.6u l=0.7u
X221 a_17764_160995# a_17764_148611# a_17764_148611# VSS nfet_06v0 ad=13.936p pd=54.12u as=13.936p ps=54.12u w=53.6u l=0.7u
X222 ESD_RAIL a_18245_90628# VSS VSS nfet_06v0 ad=13p pd=50.52u as=13p ps=50.52u w=50u l=0.7u
X223 a_17764_148611# a_17764_148611# a_17764_160995# VSS nfet_06v0 ad=13.936p pd=54.12u as=13.936p ps=54.12u w=53.6u l=0.7u
X224 ESD_RAIL a_18245_90628# VSS VSS nfet_06v0 ad=13p pd=50.52u as=13p ps=50.52u w=50u l=0.7u
X225 a_17764_148611# ESD_RAIL ESD_RAIL VSS nfet_06v0 ad=13.936p pd=54.12u as=13.936p ps=54.12u w=53.6u l=0.7u
X226 VSS a_17764_160995# a_17764_160995# VSS nfet_06v0 ad=13.936p pd=54.12u as=13.936p ps=54.12u w=53.6u l=0.7u
X227 a_17764_148611# ESD_RAIL ESD_RAIL VSS nfet_06v0 ad=13.936p pd=54.12u as=13.936p ps=54.12u w=53.6u l=0.7u
X228 a_17764_148611# ESD_RAIL ESD_RAIL VSS nfet_06v0 ad=13.936p pd=54.12u as=13.936p ps=54.12u w=53.6u l=0.7u
X229 a_17764_160995# a_17764_160995# VSS VSS nfet_06v0 ad=13.936p pd=54.12u as=23.584p ps=0.10808m w=53.6u l=0.7u
X230 a_17764_148611# a_17764_148611# a_17764_160995# VSS nfet_06v0 ad=13.936p pd=54.12u as=13.936p ps=54.12u w=53.6u l=0.7u
X231 ESD_RAIL a_20789_117064# a_18245_90628# ESD_RAIL pfet_06v0 ad=1.3p pd=5.52u as=1.3p ps=5.52u w=5u l=0.7u
X232 ESD_RAIL a_18245_90628# VSS VSS nfet_06v0 ad=13p pd=50.52u as=13p ps=50.52u w=50u l=0.7u
X233 ESD_RAIL a_18245_90628# VSS VSS nfet_06v0 ad=13p pd=50.52u as=13p ps=50.52u w=50u l=0.7u
X234 a_17764_160995# a_17764_160995# VSS VSS nfet_06v0 ad=13.936p pd=54.12u as=13.936p ps=54.12u w=53.6u l=0.7u
X235 a_17764_160995# a_17764_148611# a_17764_148611# VSS nfet_06v0 ad=13.936p pd=54.12u as=13.936p ps=54.12u w=53.6u l=0.7u
X236 a_17764_160995# a_17764_148611# a_17764_148611# VSS nfet_06v0 ad=13.936p pd=54.12u as=13.936p ps=54.12u w=53.6u l=0.7u
X237 ESD_RAIL ESD_RAIL a_17764_148611# VSS nfet_06v0 ad=13.936p pd=54.12u as=13.936p ps=54.12u w=53.6u l=0.7u
X238 VSS a_17764_160995# a_17764_160995# VSS nfet_06v0 ad=13.936p pd=54.12u as=13.936p ps=54.12u w=53.6u l=0.7u
X239 VSS a_17764_160995# a_17764_160995# VSS nfet_06v0 ad=23.584p pd=0.10808m as=13.936p ps=54.12u w=53.6u l=0.7u
X240 a_17764_160995# a_17764_148611# a_17764_148611# VSS nfet_06v0 ad=13.936p pd=54.12u as=13.936p ps=54.12u w=53.6u l=0.7u
X241 ESD_RAIL ESD_RAIL a_17764_148611# VSS nfet_06v0 ad=13.936p pd=54.12u as=13.936p ps=54.12u w=53.6u l=0.7u
X242 VSS a_17764_160995# a_17764_160995# VSS nfet_06v0 ad=13.936p pd=54.12u as=13.936p ps=54.12u w=53.6u l=0.7u
X243 VSS a_17764_160995# a_17764_160995# VSS nfet_06v0 ad=13.936p pd=54.12u as=13.936p ps=54.12u w=53.6u l=0.7u
X244 a_17764_148611# a_17764_148611# a_17764_160995# VSS nfet_06v0 ad=13.936p pd=54.12u as=23.584p ps=0.10808m w=53.6u l=0.7u
X245 VSS a_17764_160995# a_17764_160995# VSS nfet_06v0 ad=13.936p pd=54.12u as=13.936p ps=54.12u w=53.6u l=0.7u
X246 a_17764_148611# a_17764_148611# a_17764_160995# VSS nfet_06v0 ad=13.936p pd=54.12u as=23.584p ps=0.10808m w=53.6u l=0.7u
X247 a_17764_148611# a_17764_148611# a_17764_160995# VSS nfet_06v0 ad=13.936p pd=54.12u as=13.936p ps=54.12u w=53.6u l=0.7u
X248 a_17764_148611# ESD_RAIL ESD_RAIL VSS nfet_06v0 ad=13.936p pd=54.12u as=13.936p ps=54.12u w=53.6u l=0.7u
X249 a_17764_148611# ESD_RAIL ESD_RAIL VSS nfet_06v0 ad=13.936p pd=54.12u as=13.936p ps=54.12u w=53.6u l=0.7u
X250 ESD_RAIL ESD_RAIL a_17764_148611# VSS nfet_06v0 ad=13.936p pd=54.12u as=13.936p ps=54.12u w=53.6u l=0.7u
X251 a_17764_160995# a_17764_148611# a_17764_148611# VSS nfet_06v0 ad=13.936p pd=54.12u as=13.936p ps=54.12u w=53.6u l=0.7u
X252 a_17764_160995# a_17764_148611# a_17764_148611# VSS nfet_06v0 ad=13.936p pd=54.12u as=13.936p ps=54.12u w=53.6u l=0.7u
X253 ESD_RAIL ESD_RAIL a_17764_148611# VSS nfet_06v0 ad=13.936p pd=54.12u as=13.936p ps=54.12u w=53.6u l=0.7u
X254 a_17764_160995# a_17764_160995# VSS VSS nfet_06v0 ad=13.936p pd=54.12u as=13.936p ps=54.12u w=53.6u l=0.7u
X255 a_17764_160995# a_17764_148611# a_17764_148611# VSS nfet_06v0 ad=13.936p pd=54.12u as=13.936p ps=54.12u w=53.6u l=0.7u
X256 VSS a_17764_160995# a_17764_160995# VSS nfet_06v0 ad=13.936p pd=54.12u as=13.936p ps=54.12u w=53.6u l=0.7u
X257 VSS a_17764_160995# a_17764_160995# VSS nfet_06v0 ad=13.936p pd=54.12u as=13.936p ps=54.12u w=53.6u l=0.7u
X258 a_17764_148611# a_17764_148611# a_17764_160995# VSS nfet_06v0 ad=13.936p pd=54.12u as=13.936p ps=54.12u w=53.6u l=0.7u
X259 a_17764_160995# a_17764_148611# a_17764_148611# VSS nfet_06v0 ad=23.584p pd=0.10808m as=13.936p ps=54.12u w=53.6u l=0.7u
X260 a_17005_132385# a_29878_132105# ESD_RAIL ppolyf_u r_width=0.8u r_length=63.855u
X261 a_17764_148611# ESD_RAIL ESD_RAIL VSS nfet_06v0 ad=13.936p pd=54.12u as=13.936p ps=54.12u w=53.6u l=0.7u
X262 a_17764_148611# ESD_RAIL ESD_RAIL VSS nfet_06v0 ad=13.936p pd=54.12u as=13.936p ps=54.12u w=53.6u l=0.7u
X263 a_17764_160995# a_17764_160995# VSS VSS nfet_06v0 ad=13.936p pd=54.12u as=13.936p ps=54.12u w=53.6u l=0.7u
X264 ESD_RAIL ESD_RAIL a_17764_148611# VSS nfet_06v0 ad=13.936p pd=54.12u as=13.936p ps=54.12u w=53.6u l=0.7u
X265 a_17764_148611# ESD_RAIL ESD_RAIL VSS nfet_06v0 ad=13.936p pd=54.12u as=13.936p ps=54.12u w=53.6u l=0.7u
X266 a_19813_117064# a_17005_131545# ESD_RAIL ESD_RAIL pfet_06v0 ad=1.3p pd=5.52u as=1.3p ps=5.52u w=5u l=0.7u
X267 a_17764_148611# ESD_RAIL ESD_RAIL VSS nfet_06v0 ad=13.936p pd=54.12u as=13.936p ps=54.12u w=53.6u l=0.7u
X268 a_17764_160995# a_17764_160995# VSS VSS nfet_06v0 ad=13.936p pd=54.12u as=13.936p ps=54.12u w=53.6u l=0.7u
X269 a_17764_160995# a_17764_148611# a_17764_148611# VSS nfet_06v0 ad=13.936p pd=54.12u as=13.936p ps=54.12u w=53.6u l=0.7u
X270 ESD_RAIL ESD_RAIL a_17764_148611# VSS nfet_06v0 ad=13.936p pd=54.12u as=13.936p ps=54.12u w=53.6u l=0.7u
X271 VSS a_17764_160995# a_17764_160995# VSS nfet_06v0 ad=13.936p pd=54.12u as=13.936p ps=54.12u w=53.6u l=0.7u
X272 a_17764_148611# a_17764_148611# a_17764_160995# VSS nfet_06v0 ad=13.936p pd=54.12u as=13.936p ps=54.12u w=53.6u l=0.7u
X273 VSS a_18245_90628# ESD_RAIL VSS nfet_06v0 ad=13p pd=50.52u as=13p ps=50.52u w=50u l=0.7u
X274 a_17764_148611# ESD_RAIL ESD_RAIL VSS nfet_06v0 ad=13.936p pd=54.12u as=13.936p ps=54.12u w=53.6u l=0.7u
X275 a_17764_148611# a_17764_148611# a_17764_160995# VSS nfet_06v0 ad=13.936p pd=54.12u as=23.584p ps=0.10808m w=53.6u l=0.7u
X276 VSS a_17764_160995# a_17764_160995# VSS nfet_06v0 ad=13.936p pd=54.12u as=13.936p ps=54.12u w=53.6u l=0.7u
X277 a_17764_148611# a_17764_148611# a_17764_160995# VSS nfet_06v0 ad=13.936p pd=54.12u as=23.584p ps=0.10808m w=53.6u l=0.7u
X278 a_17764_148611# a_17764_148611# a_17764_160995# VSS nfet_06v0 ad=13.936p pd=54.12u as=13.936p ps=54.12u w=53.6u l=0.7u
X279 a_17764_148611# ESD_RAIL ESD_RAIL VSS nfet_06v0 ad=13.936p pd=54.12u as=13.936p ps=54.12u w=53.6u l=0.7u
X280 BIAS_N_2 BIAS_N_3 VSS ppolyf_u_1k r_width=1u r_length=12.5u
X281 a_17764_160995# a_17764_160995# VSS VSS nfet_06v0 ad=13.936p pd=54.12u as=13.936p ps=54.12u w=53.6u l=0.7u
X282 a_17764_160995# a_17764_160995# VSS VSS nfet_06v0 ad=13.936p pd=54.12u as=13.936p ps=54.12u w=53.6u l=0.7u
X283 ESD_RAIL a_18245_90628# VSS VSS nfet_06v0 ad=13p pd=50.52u as=13p ps=50.52u w=50u l=0.7u
X284 ESD_RAIL ESD_RAIL a_17764_148611# VSS nfet_06v0 ad=13.936p pd=54.12u as=23.584p ps=0.10808m w=53.6u l=0.7u
X285 ESD_RAIL ESD_RAIL a_17764_148611# VSS nfet_06v0 ad=13.936p pd=54.12u as=13.936p ps=54.12u w=53.6u l=0.7u
X286 ESD_RAIL ESD_RAIL a_17764_148611# VSS nfet_06v0 ad=13.936p pd=54.12u as=23.584p ps=0.10808m w=53.6u l=0.7u
X287 a_20789_117064# a_19813_117064# ESD_RAIL ESD_RAIL pfet_06v0 ad=2.2p pd=10.88u as=1.3p ps=5.52u w=5u l=0.7u
X288 ESD_RAIL a_17005_131545# a_19813_117064# ESD_RAIL pfet_06v0 ad=1.3p pd=5.52u as=1.3p ps=5.52u w=5u l=0.7u
X289 a_17764_160995# a_17764_148611# a_17764_148611# VSS nfet_06v0 ad=23.584p pd=0.10808m as=13.936p ps=54.12u w=53.6u l=0.7u
X290 VSS a_17764_160995# a_17764_160995# VSS nfet_06v0 ad=13.936p pd=54.12u as=13.936p ps=54.12u w=53.6u l=0.7u
X291 a_17764_148611# ESD_RAIL ESD_RAIL VSS nfet_06v0 ad=13.936p pd=54.12u as=13.936p ps=54.12u w=53.6u l=0.7u
X292 ESD_RAIL a_18245_90628# VSS VSS nfet_06v0 ad=13p pd=50.52u as=13p ps=50.52u w=50u l=0.7u
X293 a_17764_160995# a_17764_160995# VSS VSS nfet_06v0 ad=13.936p pd=54.12u as=13.936p ps=54.12u w=53.6u l=0.7u
X294 VSS a_18245_90628# ESD_RAIL VSS nfet_06v0 ad=13p pd=50.52u as=13p ps=50.52u w=50u l=0.7u
X295 a_17764_148611# a_17764_148611# a_17764_160995# VSS nfet_06v0 ad=13.936p pd=54.12u as=13.936p ps=54.12u w=53.6u l=0.7u
X296 a_17764_160995# a_17764_160995# VSS VSS nfet_06v0 ad=13.936p pd=54.12u as=13.936p ps=54.12u w=53.6u l=0.7u
X297 a_17764_160995# a_17764_148611# a_17764_148611# VSS nfet_06v0 ad=13.936p pd=54.12u as=13.936p ps=54.12u w=53.6u l=0.7u
X298 ESD_RAIL ESD_RAIL a_17764_148611# VSS nfet_06v0 ad=13.936p pd=54.12u as=13.936p ps=54.12u w=53.6u l=0.7u
X299 VSS a_17764_160995# a_17764_160995# VSS nfet_06v0 ad=13.936p pd=54.12u as=13.936p ps=54.12u w=53.6u l=0.7u
X300 ESD_RAIL ESD_RAIL a_17764_148611# VSS nfet_06v0 ad=13.936p pd=54.12u as=13.936p ps=54.12u w=53.6u l=0.7u
X301 a_17764_160995# a_17764_148611# a_17764_148611# VSS nfet_06v0 ad=13.936p pd=54.12u as=13.936p ps=54.12u w=53.6u l=0.7u
X302 a_17764_148611# ESD_RAIL ESD_RAIL VSS nfet_06v0 ad=13.936p pd=54.12u as=13.936p ps=54.12u w=53.6u l=0.7u
X303 VSS a_17764_160995# a_17764_160995# VSS nfet_06v0 ad=13.936p pd=54.12u as=13.936p ps=54.12u w=53.6u l=0.7u
X304 a_17764_148611# a_17764_148611# a_17764_160995# VSS nfet_06v0 ad=13.936p pd=54.12u as=13.936p ps=54.12u w=53.6u l=0.7u
X305 a_17764_148611# a_17764_148611# a_17764_160995# VSS nfet_06v0 ad=13.936p pd=54.12u as=13.936p ps=54.12u w=53.6u l=0.7u
X306 a_17764_148611# ESD_RAIL ESD_RAIL VSS nfet_06v0 ad=13.936p pd=54.12u as=13.936p ps=54.12u w=53.6u l=0.7u
X307 a_17764_160995# a_17764_160995# VSS VSS nfet_06v0 ad=13.936p pd=54.12u as=13.936p ps=54.12u w=53.6u l=0.7u
X308 ESD_RAIL a_18245_90628# VSS VSS nfet_06v0 ad=13p pd=50.52u as=13p ps=50.52u w=50u l=0.7u
X309 a_17764_160995# a_17764_160995# VSS VSS nfet_06v0 ad=13.936p pd=54.12u as=13.936p ps=54.12u w=53.6u l=0.7u
X310 a_18245_90628# a_20789_117064# ESD_RAIL ESD_RAIL pfet_06v0 ad=1.3p pd=5.52u as=1.3p ps=5.52u w=5u l=0.7u
X311 a_17764_160995# a_17764_148611# a_17764_148611# VSS nfet_06v0 ad=23.584p pd=0.10808m as=13.936p ps=54.12u w=53.6u l=0.7u
X312 a_17764_148611# ESD_RAIL ESD_RAIL VSS nfet_06v0 ad=13.936p pd=54.12u as=13.936p ps=54.12u w=53.6u l=0.7u
X313 VSS a_17764_160995# a_17764_160995# VSS nfet_06v0 ad=13.936p pd=54.12u as=13.936p ps=54.12u w=53.6u l=0.7u
X314 ESD_RAIL a_18245_90628# VSS VSS nfet_06v0 ad=13p pd=50.52u as=13p ps=50.52u w=50u l=0.7u
X315 a_17764_148611# ESD_RAIL ESD_RAIL VSS nfet_06v0 ad=13.936p pd=54.12u as=13.936p ps=54.12u w=53.6u l=0.7u
X316 a_17764_148611# a_17764_148611# a_17764_160995# VSS nfet_06v0 ad=13.936p pd=54.12u as=13.936p ps=54.12u w=53.6u l=0.7u
X317 VSS a_17764_160995# a_17764_160995# VSS nfet_06v0 ad=13.936p pd=54.12u as=13.936p ps=54.12u w=53.6u l=0.7u
X318 BIAS_P_3 BIAS_P_4 VSS ppolyf_u_1k r_width=1u r_length=12.5u
X319 VSS a_17764_160995# a_17764_160995# VSS nfet_06v0 ad=23.584p pd=0.10808m as=13.936p ps=54.12u w=53.6u l=0.7u
X320 a_17764_148611# a_17764_148611# a_17764_160995# VSS nfet_06v0 ad=13.936p pd=54.12u as=13.936p ps=54.12u w=53.6u l=0.7u
X321 a_17764_148611# a_17764_148611# a_17764_160995# VSS nfet_06v0 ad=13.936p pd=54.12u as=13.936p ps=54.12u w=53.6u l=0.7u
X322 ESD_RAIL ESD_RAIL a_17764_148611# VSS nfet_06v0 ad=13.936p pd=54.12u as=13.936p ps=54.12u w=53.6u l=0.7u
X323 a_17764_148611# a_17764_148611# a_17764_160995# VSS nfet_06v0 ad=13.936p pd=54.12u as=13.936p ps=54.12u w=53.6u l=0.7u
X324 VSS a_18245_90628# ESD_RAIL VSS nfet_06v0 ad=13p pd=50.52u as=22p ps=0.10088m w=50u l=0.7u
X325 a_17005_131825# a_29878_132105# ESD_RAIL ppolyf_u r_width=0.8u r_length=63.855u
X326 a_17764_148611# a_17764_148611# a_17764_160995# VSS nfet_06v0 ad=13.936p pd=54.12u as=23.584p ps=0.10808m w=53.6u l=0.7u
X327 a_17764_160995# a_17764_148611# a_17764_148611# VSS nfet_06v0 ad=13.936p pd=54.12u as=13.936p ps=54.12u w=53.6u l=0.7u
X328 ESD_RAIL ESD_RAIL a_17764_148611# VSS nfet_06v0 ad=13.936p pd=54.12u as=13.936p ps=54.12u w=53.6u l=0.7u
X329 ESD_RAIL ESD_RAIL a_17764_148611# VSS nfet_06v0 ad=13.936p pd=54.12u as=13.936p ps=54.12u w=53.6u l=0.7u
X330 VSS a_17764_160995# a_17764_160995# VSS nfet_06v0 ad=13.936p pd=54.12u as=13.936p ps=54.12u w=53.6u l=0.7u
X331 VSS a_18245_90628# ESD_RAIL VSS nfet_06v0 ad=13p pd=50.52u as=22p ps=0.10088m w=50u l=0.7u
X332 a_17764_148611# ESD_RAIL ESD_RAIL VSS nfet_06v0 ad=13.936p pd=54.12u as=13.936p ps=54.12u w=53.6u l=0.7u
X333 ESD_RAIL a_20789_117064# a_18245_90628# ESD_RAIL pfet_06v0 ad=1.3p pd=5.52u as=1.3p ps=5.52u w=5u l=0.7u
X334 ESD_RAIL a_18245_90628# VSS VSS nfet_06v0 ad=13p pd=50.52u as=13p ps=50.52u w=50u l=0.7u
X335 a_17764_148611# a_17764_148611# a_17764_160995# VSS nfet_06v0 ad=13.936p pd=54.12u as=13.936p ps=54.12u w=53.6u l=0.7u
X336 ESD_RAIL ESD_RAIL a_17764_148611# VSS nfet_06v0 ad=13.936p pd=54.12u as=23.584p ps=0.10808m w=53.6u l=0.7u
X337 a_17764_160995# a_17764_160995# VSS VSS nfet_06v0 ad=13.936p pd=54.12u as=13.936p ps=54.12u w=53.6u l=0.7u
X338 a_17764_160995# a_17764_148611# a_17764_148611# VSS nfet_06v0 ad=13.936p pd=54.12u as=13.936p ps=54.12u w=53.6u l=0.7u
X339 ESD_RAIL ESD_RAIL a_17764_148611# VSS nfet_06v0 ad=13.936p pd=54.12u as=13.936p ps=54.12u w=53.6u l=0.7u
X340 a_17764_160995# a_17764_148611# a_17764_148611# VSS nfet_06v0 ad=23.584p pd=0.10808m as=13.936p ps=54.12u w=53.6u l=0.7u
X341 a_17764_160995# a_17764_160995# VSS VSS nfet_06v0 ad=13.936p pd=54.12u as=13.936p ps=54.12u w=53.6u l=0.7u
X342 ESD_RAIL a_19813_117064# a_20789_117064# ESD_RAIL pfet_06v0 ad=1.3p pd=5.52u as=1.3p ps=5.52u w=5u l=0.7u
X343 a_17764_160995# a_17764_148611# a_17764_148611# VSS nfet_06v0 ad=13.936p pd=54.12u as=13.936p ps=54.12u w=53.6u l=0.7u
X344 a_17764_160995# a_17764_148611# a_17764_148611# VSS nfet_06v0 ad=13.936p pd=54.12u as=13.936p ps=54.12u w=53.6u l=0.7u
X345 ESD_RAIL ESD_RAIL a_17764_148611# VSS nfet_06v0 ad=13.936p pd=54.12u as=13.936p ps=54.12u w=53.6u l=0.7u
X346 a_17764_160995# a_17764_148611# a_17764_148611# VSS nfet_06v0 ad=13.936p pd=54.12u as=13.936p ps=54.12u w=53.6u l=0.7u
D6 PAD_P ESD_RAIL diode_pd2nw_06v0 pj=51.8u area=22.5p
X347 VSS a_17764_160995# a_17764_160995# VSS nfet_06v0 ad=23.584p pd=0.10808m as=13.936p ps=54.12u w=53.6u l=0.7u
X348 a_17764_148611# ESD_RAIL ESD_RAIL VSS nfet_06v0 ad=13.936p pd=54.12u as=13.936p ps=54.12u w=53.6u l=0.7u
X349 VSS a_18245_90628# ESD_RAIL VSS nfet_06v0 ad=13p pd=50.52u as=13p ps=50.52u w=50u l=0.7u
X350 VSS a_18245_90628# ESD_RAIL VSS nfet_06v0 ad=13p pd=50.52u as=13p ps=50.52u w=50u l=0.7u
X351 a_17764_148611# ESD_RAIL ESD_RAIL VSS nfet_06v0 ad=13.936p pd=54.12u as=13.936p ps=54.12u w=53.6u l=0.7u
X352 a_17764_148611# a_17764_148611# a_17764_160995# VSS nfet_06v0 ad=13.936p pd=54.12u as=13.936p ps=54.12u w=53.6u l=0.7u
X353 ESD_RAIL a_18245_90628# VSS VSS nfet_06v0 ad=13p pd=50.52u as=13p ps=50.52u w=50u l=0.7u
D7 VSS PAD_N diode_nd2ps_06v0 pj=51.8u area=22.5p
X354 a_17764_160995# a_17764_160995# VSS VSS nfet_06v0 ad=13.936p pd=54.12u as=13.936p ps=54.12u w=53.6u l=0.7u
X355 a_17764_160995# a_17764_148611# a_17764_148611# VSS nfet_06v0 ad=13.936p pd=54.12u as=13.936p ps=54.12u w=53.6u l=0.7u
X356 ESD_RAIL a_20789_117064# a_18245_90628# ESD_RAIL pfet_06v0 ad=1.3p pd=5.52u as=1.3p ps=5.52u w=5u l=0.7u
X357 a_18245_90628# a_20789_117064# ESD_RAIL ESD_RAIL pfet_06v0 ad=1.3p pd=5.52u as=1.3p ps=5.52u w=5u l=0.7u
X358 a_17764_160995# a_17764_160995# VSS VSS nfet_06v0 ad=13.936p pd=54.12u as=13.936p ps=54.12u w=53.6u l=0.7u
X359 a_17764_160995# a_17764_148611# a_17764_148611# VSS nfet_06v0 ad=13.936p pd=54.12u as=13.936p ps=54.12u w=53.6u l=0.7u
X360 ESD_RAIL ESD_RAIL a_17764_148611# VSS nfet_06v0 ad=13.936p pd=54.12u as=13.936p ps=54.12u w=53.6u l=0.7u
X361 ESD_RAIL ESD_RAIL a_17764_148611# VSS nfet_06v0 ad=13.936p pd=54.12u as=13.936p ps=54.12u w=53.6u l=0.7u
X362 VSS a_17764_160995# a_17764_160995# VSS nfet_06v0 ad=13.936p pd=54.12u as=13.936p ps=54.12u w=53.6u l=0.7u
X363 VSS a_17764_160995# a_17764_160995# VSS nfet_06v0 ad=13.936p pd=54.12u as=13.936p ps=54.12u w=53.6u l=0.7u
X364 a_17764_148611# a_17764_148611# a_17764_160995# VSS nfet_06v0 ad=13.936p pd=54.12u as=13.936p ps=54.12u w=53.6u l=0.7u
X365 ESD_RAIL a_18245_90628# VSS VSS nfet_06v0 ad=22p pd=0.10088m as=13p ps=50.52u w=50u l=0.7u
X366 a_17764_148611# ESD_RAIL ESD_RAIL VSS nfet_06v0 ad=13.936p pd=54.12u as=13.936p ps=54.12u w=53.6u l=0.7u
X367 a_17764_148611# ESD_RAIL ESD_RAIL VSS nfet_06v0 ad=13.936p pd=54.12u as=13.936p ps=54.12u w=53.6u l=0.7u
X368 a_17764_160995# a_17764_148611# a_17764_148611# VSS nfet_06v0 ad=13.936p pd=54.12u as=13.936p ps=54.12u w=53.6u l=0.7u
X369 a_17764_148611# a_17764_148611# a_17764_160995# VSS nfet_06v0 ad=13.936p pd=54.12u as=13.936p ps=54.12u w=53.6u l=0.7u
X370 a_17005_132945# a_29878_133225# ESD_RAIL ppolyf_u r_width=0.8u r_length=63.855u
X371 a_17764_148611# ESD_RAIL ESD_RAIL VSS nfet_06v0 ad=13.936p pd=54.12u as=13.936p ps=54.12u w=53.6u l=0.7u
X372 a_17764_160995# a_17764_160995# VSS VSS nfet_06v0 ad=13.936p pd=54.12u as=13.936p ps=54.12u w=53.6u l=0.7u
X373 a_17764_160995# a_17764_160995# VSS VSS nfet_06v0 ad=13.936p pd=54.12u as=13.936p ps=54.12u w=53.6u l=0.7u
X374 a_17764_148611# ESD_RAIL ESD_RAIL VSS nfet_06v0 ad=13.936p pd=54.12u as=13.936p ps=54.12u w=53.6u l=0.7u
X375 a_17764_160995# a_17764_148611# a_17764_148611# VSS nfet_06v0 ad=13.936p pd=54.12u as=13.936p ps=54.12u w=53.6u l=0.7u
X376 VSS a_17764_160995# a_17764_160995# VSS nfet_06v0 ad=13.936p pd=54.12u as=13.936p ps=54.12u w=53.6u l=0.7u
X377 a_17764_160995# a_17764_160995# VSS VSS nfet_06v0 ad=13.936p pd=54.12u as=13.936p ps=54.12u w=53.6u l=0.7u
X378 VSS a_17764_160995# a_17764_160995# VSS nfet_06v0 ad=13.936p pd=54.12u as=13.936p ps=54.12u w=53.6u l=0.7u
X379 VSS a_17764_160995# a_17764_160995# VSS nfet_06v0 ad=23.584p pd=0.10808m as=13.936p ps=54.12u w=53.6u l=0.7u
X380 a_17764_148611# a_17764_148611# a_17764_160995# VSS nfet_06v0 ad=13.936p pd=54.12u as=13.936p ps=54.12u w=53.6u l=0.7u
X381 a_17764_148611# a_17764_148611# a_17764_160995# VSS nfet_06v0 ad=13.936p pd=54.12u as=13.936p ps=54.12u w=53.6u l=0.7u
X382 a_17764_148611# ESD_RAIL ESD_RAIL VSS nfet_06v0 ad=13.936p pd=54.12u as=13.936p ps=54.12u w=53.6u l=0.7u
X383 ESD_RAIL ESD_RAIL a_17764_148611# VSS nfet_06v0 ad=13.936p pd=54.12u as=13.936p ps=54.12u w=53.6u l=0.7u
X384 a_20789_117064# a_19813_117064# ESD_RAIL ESD_RAIL pfet_06v0 ad=1.3p pd=5.52u as=1.3p ps=5.52u w=5u l=0.7u
X385 ESD_RAIL ESD_RAIL a_17764_148611# VSS nfet_06v0 ad=13.936p pd=54.12u as=13.936p ps=54.12u w=53.6u l=0.7u
X386 a_17764_160995# a_17764_160995# VSS VSS nfet_06v0 ad=13.936p pd=54.12u as=13.936p ps=54.12u w=53.6u l=0.7u
X387 a_17764_160995# a_17764_148611# a_17764_148611# VSS nfet_06v0 ad=13.936p pd=54.12u as=13.936p ps=54.12u w=53.6u l=0.7u
X388 a_17764_148611# a_17764_148611# a_17764_160995# VSS nfet_06v0 ad=13.936p pd=54.12u as=13.936p ps=54.12u w=53.6u l=0.7u
X389 a_17764_148611# ESD_RAIL ESD_RAIL VSS nfet_06v0 ad=13.936p pd=54.12u as=13.936p ps=54.12u w=53.6u l=0.7u
X390 ESD_RAIL ESD_RAIL a_17764_148611# VSS nfet_06v0 ad=13.936p pd=54.12u as=23.584p ps=0.10808m w=53.6u l=0.7u
X391 ESD_RAIL ESD_RAIL a_17764_148611# VSS nfet_06v0 ad=13.936p pd=54.12u as=13.936p ps=54.12u w=53.6u l=0.7u
X392 a_17764_148611# ESD_RAIL ESD_RAIL VSS nfet_06v0 ad=13.936p pd=54.12u as=13.936p ps=54.12u w=53.6u l=0.7u
X393 a_17764_160995# a_17764_160995# VSS VSS nfet_06v0 ad=13.936p pd=54.12u as=23.584p ps=0.10808m w=53.6u l=0.7u
X394 a_18245_90628# VSS VSS ppolyf_u_1k_6p0 r_width=1u r_length=99.24u
X395 BIAS_P_2 BIAS_P_3 VSS ppolyf_u_1k r_width=1u r_length=12.5u
X396 a_17764_148611# a_17764_148611# a_17764_160995# VSS nfet_06v0 ad=13.936p pd=54.12u as=13.936p ps=54.12u w=53.6u l=0.7u
X397 ESD_RAIL a_18245_90628# VSS VSS nfet_06v0 ad=13p pd=50.52u as=13p ps=50.52u w=50u l=0.7u
X398 a_17764_148611# ESD_RAIL ESD_RAIL VSS nfet_06v0 ad=13.936p pd=54.12u as=13.936p ps=54.12u w=53.6u l=0.7u
X399 a_17764_160995# a_17764_160995# VSS VSS nfet_06v0 ad=13.936p pd=54.12u as=13.936p ps=54.12u w=53.6u l=0.7u
X400 a_17764_148611# ESD_RAIL ESD_RAIL VSS nfet_06v0 ad=13.936p pd=54.12u as=13.936p ps=54.12u w=53.6u l=0.7u
X401 a_17764_160995# a_17764_160995# VSS VSS nfet_06v0 ad=13.936p pd=54.12u as=13.936p ps=54.12u w=53.6u l=0.7u
X402 a_17764_160995# a_17764_160995# VSS VSS nfet_06v0 ad=13.936p pd=54.12u as=13.936p ps=54.12u w=53.6u l=0.7u
X403 a_17764_160995# a_17764_148611# a_17764_148611# VSS nfet_06v0 ad=13.936p pd=54.12u as=13.936p ps=54.12u w=53.6u l=0.7u
X404 ESD_RAIL ESD_RAIL a_17764_148611# VSS nfet_06v0 ad=13.936p pd=54.12u as=13.936p ps=54.12u w=53.6u l=0.7u
X405 a_17764_148611# ESD_RAIL ESD_RAIL VSS nfet_06v0 ad=13.936p pd=54.12u as=13.936p ps=54.12u w=53.6u l=0.7u
X406 a_17764_160995# a_17764_148611# a_17764_148611# VSS nfet_06v0 ad=13.936p pd=54.12u as=13.936p ps=54.12u w=53.6u l=0.7u
X407 VSS a_17764_160995# a_17764_160995# VSS nfet_06v0 ad=13.936p pd=54.12u as=13.936p ps=54.12u w=53.6u l=0.7u
X408 VSS a_17764_160995# a_17764_160995# VSS nfet_06v0 ad=13.936p pd=54.12u as=13.936p ps=54.12u w=53.6u l=0.7u
X409 a_17764_148611# a_17764_148611# a_17764_160995# VSS nfet_06v0 ad=13.936p pd=54.12u as=13.936p ps=54.12u w=53.6u l=0.7u
X410 a_17764_148611# a_17764_148611# a_17764_160995# VSS nfet_06v0 ad=13.936p pd=54.12u as=13.936p ps=54.12u w=53.6u l=0.7u
X411 a_17005_134065# a_29878_134345# ESD_RAIL ppolyf_u r_width=0.8u r_length=63.855u
X412 a_17764_160995# a_17764_160995# VSS VSS nfet_06v0 ad=13.936p pd=54.12u as=13.936p ps=54.12u w=53.6u l=0.7u
X413 VSS a_17764_160995# a_17764_160995# VSS nfet_06v0 ad=13.936p pd=54.12u as=13.936p ps=54.12u w=53.6u l=0.7u
D8 PAD_N ESD_RAIL diode_pd2nw_06v0 pj=51.8u area=22.5p
X414 ESD_RAIL ESD_RAIL a_17764_148611# VSS nfet_06v0 ad=13.936p pd=54.12u as=13.936p ps=54.12u w=53.6u l=0.7u
X415 ESD_RAIL a_18245_90628# VSS VSS nfet_06v0 ad=13p pd=50.52u as=13p ps=50.52u w=50u l=0.7u
X416 ESD_RAIL ESD_RAIL a_17764_148611# VSS nfet_06v0 ad=13.936p pd=54.12u as=13.936p ps=54.12u w=53.6u l=0.7u
X417 a_17764_160995# a_17764_148611# a_17764_148611# VSS nfet_06v0 ad=13.936p pd=54.12u as=13.936p ps=54.12u w=53.6u l=0.7u
X418 ESD_RAIL a_18245_90628# VSS VSS nfet_06v0 ad=13p pd=50.52u as=13p ps=50.52u w=50u l=0.7u
X419 ESD_RAIL ESD_RAIL a_17764_148611# VSS nfet_06v0 ad=13.936p pd=54.12u as=23.584p ps=0.10808m w=53.6u l=0.7u
X420 a_17764_160995# a_17764_148611# a_17764_148611# VSS nfet_06v0 ad=13.936p pd=54.12u as=13.936p ps=54.12u w=53.6u l=0.7u
X421 ESD_RAIL VSS cap_mim_2f0_m4m5_noshield c_width=31.6u c_length=31.6u
X422 a_17764_160995# a_17764_148611# a_17764_148611# VSS nfet_06v0 ad=23.584p pd=0.10808m as=13.936p ps=54.12u w=53.6u l=0.7u
X423 a_17764_148611# ESD_RAIL ESD_RAIL VSS nfet_06v0 ad=13.936p pd=54.12u as=13.936p ps=54.12u w=53.6u l=0.7u
X424 a_17764_148611# ESD_RAIL ESD_RAIL VSS nfet_06v0 ad=13.936p pd=54.12u as=13.936p ps=54.12u w=53.6u l=0.7u
X425 ESD_RAIL ESD_RAIL a_17764_148611# VSS nfet_06v0 ad=13.936p pd=54.12u as=13.936p ps=54.12u w=53.6u l=0.7u
X426 a_17764_160995# a_17764_160995# VSS VSS nfet_06v0 ad=13.936p pd=54.12u as=13.936p ps=54.12u w=53.6u l=0.7u
X427 a_17764_160995# a_17764_148611# a_17764_148611# VSS nfet_06v0 ad=13.936p pd=54.12u as=13.936p ps=54.12u w=53.6u l=0.7u
X428 BIAS_N_4 BIAS_N_5 VSS ppolyf_u_1k r_width=1u r_length=12.5u
X429 VSS a_17764_160995# a_17764_160995# VSS nfet_06v0 ad=13.936p pd=54.12u as=13.936p ps=54.12u w=53.6u l=0.7u
X430 a_17764_160995# a_17764_160995# VSS VSS nfet_06v0 ad=13.936p pd=54.12u as=13.936p ps=54.12u w=53.6u l=0.7u
X431 ESD_RAIL a_18245_90628# VSS VSS nfet_06v0 ad=13p pd=50.52u as=13p ps=50.52u w=50u l=0.7u
X432 a_17764_148611# ESD_RAIL ESD_RAIL VSS nfet_06v0 ad=13.936p pd=54.12u as=13.936p ps=54.12u w=53.6u l=0.7u
X433 VSS a_17764_160995# a_17764_160995# VSS nfet_06v0 ad=13.936p pd=54.12u as=13.936p ps=54.12u w=53.6u l=0.7u
X434 ESD_RAIL a_18245_90628# VSS VSS nfet_06v0 ad=13p pd=50.52u as=13p ps=50.52u w=50u l=0.7u
X435 a_17764_148611# ESD_RAIL ESD_RAIL VSS nfet_06v0 ad=13.936p pd=54.12u as=13.936p ps=54.12u w=53.6u l=0.7u
X436 VSS a_17764_160995# a_17764_160995# VSS nfet_06v0 ad=13.936p pd=54.12u as=13.936p ps=54.12u w=53.6u l=0.7u
X437 a_17764_148611# a_17764_148611# a_17764_160995# VSS nfet_06v0 ad=13.936p pd=54.12u as=13.936p ps=54.12u w=53.6u l=0.7u
X438 a_17764_160995# a_17764_160995# VSS VSS nfet_06v0 ad=13.936p pd=54.12u as=13.936p ps=54.12u w=53.6u l=0.7u
X439 a_17764_148611# a_17764_148611# a_17764_160995# VSS nfet_06v0 ad=13.936p pd=54.12u as=13.936p ps=54.12u w=53.6u l=0.7u
X440 ESD_RAIL ESD_RAIL a_17764_148611# VSS nfet_06v0 ad=13.936p pd=54.12u as=13.936p ps=54.12u w=53.6u l=0.7u
X441 a_17764_148611# ESD_RAIL ESD_RAIL VSS nfet_06v0 ad=13.936p pd=54.12u as=13.936p ps=54.12u w=53.6u l=0.7u
X442 a_17764_160995# a_17764_148611# a_17764_148611# VSS nfet_06v0 ad=23.584p pd=0.10808m as=13.936p ps=54.12u w=53.6u l=0.7u
X443 a_17764_148611# ESD_RAIL ESD_RAIL VSS nfet_06v0 ad=13.936p pd=54.12u as=13.936p ps=54.12u w=53.6u l=0.7u
X444 a_17764_148611# a_17764_148611# a_17764_160995# VSS nfet_06v0 ad=13.936p pd=54.12u as=13.936p ps=54.12u w=53.6u l=0.7u
X445 a_17764_148611# a_17764_148611# a_17764_160995# VSS nfet_06v0 ad=13.936p pd=54.12u as=13.936p ps=54.12u w=53.6u l=0.7u
X446 VSS a_19813_117064# a_20789_117064# VSS nfet_06v0 ad=1.3p pd=5.52u as=1.3p ps=5.52u w=5u l=0.7u
X447 a_17764_160995# a_17764_160995# VSS VSS nfet_06v0 ad=13.936p pd=54.12u as=13.936p ps=54.12u w=53.6u l=0.7u
X448 a_17764_160995# a_17764_148611# a_17764_148611# VSS nfet_06v0 ad=13.936p pd=54.12u as=13.936p ps=54.12u w=53.6u l=0.7u
X449 VSS a_18245_90628# ESD_RAIL VSS nfet_06v0 ad=13p pd=50.52u as=13p ps=50.52u w=50u l=0.7u
X450 ESD_RAIL ESD_RAIL a_17764_148611# VSS nfet_06v0 ad=13.936p pd=54.12u as=13.936p ps=54.12u w=53.6u l=0.7u
X451 ESD_RAIL ESD_RAIL a_17764_148611# VSS nfet_06v0 ad=13.936p pd=54.12u as=13.936p ps=54.12u w=53.6u l=0.7u
X452 VSS a_17764_160995# a_17764_160995# VSS nfet_06v0 ad=13.936p pd=54.12u as=13.936p ps=54.12u w=53.6u l=0.7u
X453 a_17764_160995# a_17764_148611# a_17764_148611# VSS nfet_06v0 ad=13.936p pd=54.12u as=13.936p ps=54.12u w=53.6u l=0.7u
X454 ESD_RAIL ESD_RAIL a_17764_148611# VSS nfet_06v0 ad=13.936p pd=54.12u as=13.936p ps=54.12u w=53.6u l=0.7u
X455 VSS a_17764_160995# a_17764_160995# VSS nfet_06v0 ad=13.936p pd=54.12u as=13.936p ps=54.12u w=53.6u l=0.7u
X456 a_17764_148611# ESD_RAIL ESD_RAIL VSS nfet_06v0 ad=13.936p pd=54.12u as=13.936p ps=54.12u w=53.6u l=0.7u
X457 ESD_RAIL ESD_RAIL a_17764_148611# VSS nfet_06v0 ad=13.936p pd=54.12u as=13.936p ps=54.12u w=53.6u l=0.7u
X458 a_17764_148611# a_17764_148611# a_17764_160995# VSS nfet_06v0 ad=13.936p pd=54.12u as=13.936p ps=54.12u w=53.6u l=0.7u
X459 a_17764_148611# a_17764_148611# a_17764_160995# VSS nfet_06v0 ad=13.936p pd=54.12u as=13.936p ps=54.12u w=53.6u l=0.7u
X460 a_17764_160995# a_17764_160995# VSS VSS nfet_06v0 ad=13.936p pd=54.12u as=13.936p ps=54.12u w=53.6u l=0.7u
X461 VSS a_20789_117064# a_18245_90628# VSS nfet_06v0 ad=1.3p pd=5.52u as=1.3p ps=5.52u w=5u l=0.7u
X462 a_17764_160995# a_17764_148611# a_17764_148611# VSS nfet_06v0 ad=13.936p pd=54.12u as=13.936p ps=54.12u w=53.6u l=0.7u
X463 a_17764_148611# a_17764_148611# a_17764_160995# VSS nfet_06v0 ad=13.936p pd=54.12u as=13.936p ps=54.12u w=53.6u l=0.7u
X464 a_17764_160995# a_17764_160995# VSS VSS nfet_06v0 ad=13.936p pd=54.12u as=13.936p ps=54.12u w=53.6u l=0.7u
X465 a_17764_160995# a_17764_160995# VSS VSS nfet_06v0 ad=13.936p pd=54.12u as=13.936p ps=54.12u w=53.6u l=0.7u
X466 a_17764_160995# a_17764_148611# a_17764_148611# VSS nfet_06v0 ad=13.936p pd=54.12u as=13.936p ps=54.12u w=53.6u l=0.7u
X467 a_17764_160995# a_17764_148611# a_17764_148611# VSS nfet_06v0 ad=23.584p pd=0.10808m as=13.936p ps=54.12u w=53.6u l=0.7u
X468 VSS a_18245_90628# ESD_RAIL VSS nfet_06v0 ad=13p pd=50.52u as=13p ps=50.52u w=50u l=0.7u
X469 VSS a_18245_90628# ESD_RAIL VSS nfet_06v0 ad=13p pd=50.52u as=13p ps=50.52u w=50u l=0.7u
X470 VSS a_20789_117064# a_18245_90628# VSS nfet_06v0 ad=1.3p pd=5.52u as=1.3p ps=5.52u w=5u l=0.7u
D9 VSS PAD_P diode_nd2ps_06v0 pj=51.8u area=22.5p
X471 ESD_RAIL a_20789_117064# a_18245_90628# ESD_RAIL pfet_06v0 ad=1.3p pd=5.52u as=1.3p ps=5.52u w=5u l=0.7u
X472 a_17764_148611# ESD_RAIL ESD_RAIL VSS nfet_06v0 ad=13.936p pd=54.12u as=13.936p ps=54.12u w=53.6u l=0.7u
X473 a_17764_160995# a_17764_160995# VSS VSS nfet_06v0 ad=13.936p pd=54.12u as=13.936p ps=54.12u w=53.6u l=0.7u
X474 a_17764_148611# ESD_RAIL ESD_RAIL VSS nfet_06v0 ad=23.584p pd=0.10808m as=13.936p ps=54.12u w=53.6u l=0.7u
X475 a_17764_148611# ESD_RAIL ESD_RAIL VSS nfet_06v0 ad=13.936p pd=54.12u as=13.936p ps=54.12u w=53.6u l=0.7u
X476 a_17764_160995# a_17764_160995# VSS VSS nfet_06v0 ad=13.936p pd=54.12u as=13.936p ps=54.12u w=53.6u l=0.7u
X477 VSS a_17764_160995# a_17764_160995# VSS nfet_06v0 ad=23.584p pd=0.10808m as=13.936p ps=54.12u w=53.6u l=0.7u
X478 a_17764_160995# a_17764_160995# VSS VSS nfet_06v0 ad=13.936p pd=54.12u as=13.936p ps=54.12u w=53.6u l=0.7u
X479 a_17764_148611# a_17764_148611# a_17764_160995# VSS nfet_06v0 ad=13.936p pd=54.12u as=13.936p ps=54.12u w=53.6u l=0.7u
X480 ESD_RAIL ESD_RAIL a_17764_148611# VSS nfet_06v0 ad=13.936p pd=54.12u as=13.936p ps=54.12u w=53.6u l=0.7u
X481 VSS a_17764_160995# a_17764_160995# VSS nfet_06v0 ad=13.936p pd=54.12u as=13.936p ps=54.12u w=53.6u l=0.7u
X482 a_17764_148611# a_17764_148611# a_17764_160995# VSS nfet_06v0 ad=13.936p pd=54.12u as=23.584p ps=0.10808m w=53.6u l=0.7u
X483 ESD_RAIL a_18245_90628# VSS VSS nfet_06v0 ad=13p pd=50.52u as=13p ps=50.52u w=50u l=0.7u
X484 a_17764_148611# a_17764_148611# a_17764_160995# VSS nfet_06v0 ad=13.936p pd=54.12u as=13.936p ps=54.12u w=53.6u l=0.7u
X485 a_17764_148611# ESD_RAIL ESD_RAIL VSS nfet_06v0 ad=13.936p pd=54.12u as=13.936p ps=54.12u w=53.6u l=0.7u
X486 a_17764_148611# a_17764_148611# a_17764_160995# VSS nfet_06v0 ad=13.936p pd=54.12u as=13.936p ps=54.12u w=53.6u l=0.7u
X487 a_17764_148611# a_17764_148611# a_17764_160995# VSS nfet_06v0 ad=13.936p pd=54.12u as=13.936p ps=54.12u w=53.6u l=0.7u
X488 a_17764_148611# ESD_RAIL ESD_RAIL VSS nfet_06v0 ad=13.936p pd=54.12u as=13.936p ps=54.12u w=53.6u l=0.7u
X489 a_17764_160995# a_17764_160995# VSS VSS nfet_06v0 ad=13.936p pd=54.12u as=13.936p ps=54.12u w=53.6u l=0.7u
X490 a_20789_117064# a_19813_117064# VSS VSS nfet_06v0 ad=1.3p pd=5.52u as=1.3p ps=5.52u w=5u l=0.7u
X491 VSS a_18245_90628# ESD_RAIL VSS nfet_06v0 ad=13p pd=50.52u as=13p ps=50.52u w=50u l=0.7u
X492 ESD_RAIL ESD_RAIL a_17764_148611# VSS nfet_06v0 ad=13.936p pd=54.12u as=13.936p ps=54.12u w=53.6u l=0.7u
X493 ESD_RAIL ESD_RAIL a_17764_148611# VSS nfet_06v0 ad=13.936p pd=54.12u as=13.936p ps=54.12u w=53.6u l=0.7u
X494 a_17764_160995# a_17764_148611# a_17764_148611# VSS nfet_06v0 ad=13.936p pd=54.12u as=13.936p ps=54.12u w=53.6u l=0.7u
X495 a_17764_160995# a_17764_148611# a_17764_148611# VSS nfet_06v0 ad=13.936p pd=54.12u as=13.936p ps=54.12u w=53.6u l=0.7u
X496 VSS a_17764_160995# a_17764_160995# VSS nfet_06v0 ad=13.936p pd=54.12u as=13.936p ps=54.12u w=53.6u l=0.7u
X497 a_17764_148611# a_17764_148611# a_17764_160995# VSS nfet_06v0 ad=13.936p pd=54.12u as=13.936p ps=54.12u w=53.6u l=0.7u
X498 a_17764_160995# a_17764_148611# a_17764_148611# VSS nfet_06v0 ad=13.936p pd=54.12u as=13.936p ps=54.12u w=53.6u l=0.7u
X499 VSS a_17764_160995# a_17764_160995# VSS nfet_06v0 ad=23.584p pd=0.10808m as=13.936p ps=54.12u w=53.6u l=0.7u
X500 a_17764_148611# ESD_RAIL ESD_RAIL VSS nfet_06v0 ad=23.584p pd=0.10808m as=13.936p ps=54.12u w=53.6u l=0.7u
X501 a_17764_160995# a_17764_160995# VSS VSS nfet_06v0 ad=13.936p pd=54.12u as=13.936p ps=54.12u w=53.6u l=0.7u
X502 BIAS_P_6 VCM VSS ppolyf_u_1k r_width=1u r_length=12.5u
X503 ESD_RAIL ESD_RAIL a_17764_148611# VSS nfet_06v0 ad=13.936p pd=54.12u as=13.936p ps=54.12u w=53.6u l=0.7u
X504 ESD_RAIL ESD_RAIL a_17764_148611# VSS nfet_06v0 ad=13.936p pd=54.12u as=13.936p ps=54.12u w=53.6u l=0.7u
X505 ESD_RAIL a_18245_90628# VSS VSS nfet_06v0 ad=13p pd=50.52u as=13p ps=50.52u w=50u l=0.7u
X506 VSS a_17764_160995# a_17764_160995# VSS nfet_06v0 ad=13.936p pd=54.12u as=13.936p ps=54.12u w=53.6u l=0.7u
X507 a_17764_160995# a_17764_148611# a_17764_148611# VSS nfet_06v0 ad=13.936p pd=54.12u as=13.936p ps=54.12u w=53.6u l=0.7u
X508 a_17764_148611# a_17764_148611# a_17764_160995# VSS nfet_06v0 ad=13.936p pd=54.12u as=13.936p ps=54.12u w=53.6u l=0.7u
X509 a_17764_148611# a_17764_148611# a_17764_160995# VSS nfet_06v0 ad=13.936p pd=54.12u as=13.936p ps=54.12u w=53.6u l=0.7u
X510 a_17764_148611# ESD_RAIL ESD_RAIL VSS nfet_06v0 ad=13.936p pd=54.12u as=13.936p ps=54.12u w=53.6u l=0.7u
X511 a_17764_160995# a_17764_160995# VSS VSS nfet_06v0 ad=13.936p pd=54.12u as=13.936p ps=54.12u w=53.6u l=0.7u
X512 ESD_RAIL ESD_RAIL a_17764_148611# VSS nfet_06v0 ad=13.936p pd=54.12u as=13.936p ps=54.12u w=53.6u l=0.7u
X513 a_17764_160995# a_17764_148611# a_17764_148611# VSS nfet_06v0 ad=13.936p pd=54.12u as=13.936p ps=54.12u w=53.6u l=0.7u
X514 a_17764_160995# a_17764_148611# a_17764_148611# VSS nfet_06v0 ad=13.936p pd=54.12u as=13.936p ps=54.12u w=53.6u l=0.7u
X515 a_17764_148611# ESD_RAIL ESD_RAIL VSS nfet_06v0 ad=13.936p pd=54.12u as=13.936p ps=54.12u w=53.6u l=0.7u
X516 VSS a_17764_160995# a_17764_160995# VSS nfet_06v0 ad=23.584p pd=0.10808m as=13.936p ps=54.12u w=53.6u l=0.7u
X517 VSS a_18245_90628# ESD_RAIL VSS nfet_06v0 ad=13p pd=50.52u as=13p ps=50.52u w=50u l=0.7u
X518 a_17764_148611# a_17764_148611# a_17764_160995# VSS nfet_06v0 ad=13.936p pd=54.12u as=13.936p ps=54.12u w=53.6u l=0.7u
X519 ESD_RAIL a_18245_90628# VSS VSS nfet_06v0 ad=13p pd=50.52u as=13p ps=50.52u w=50u l=0.7u
D10 VSS ESD_RAIL diode_nd2ps_06v0 pj=82u area=40p
X520 a_17764_148611# ESD_RAIL ESD_RAIL VSS nfet_06v0 ad=13.936p pd=54.12u as=13.936p ps=54.12u w=53.6u l=0.7u
X521 ESD_RAIL ESD_RAIL a_17764_148611# VSS nfet_06v0 ad=13.936p pd=54.12u as=13.936p ps=54.12u w=53.6u l=0.7u
D11 VSS ESD_RAIL diode_nd2ps_06v0 pj=82u area=40p
X522 ESD_RAIL ESD_RAIL a_17764_148611# VSS nfet_06v0 ad=13.936p pd=54.12u as=23.584p ps=0.10808m w=53.6u l=0.7u
X523 a_17764_148611# ESD_RAIL ESD_RAIL VSS nfet_06v0 ad=13.936p pd=54.12u as=13.936p ps=54.12u w=53.6u l=0.7u
X524 a_17764_148611# a_17764_148611# a_17764_160995# VSS nfet_06v0 ad=13.936p pd=54.12u as=13.936p ps=54.12u w=53.6u l=0.7u
X525 VSS a_18245_90628# ESD_RAIL VSS nfet_06v0 ad=13p pd=50.52u as=13p ps=50.52u w=50u l=0.7u
X526 a_17764_160995# a_17764_160995# VSS VSS nfet_06v0 ad=13.936p pd=54.12u as=13.936p ps=54.12u w=53.6u l=0.7u
X527 a_17764_148611# ESD_RAIL ESD_RAIL VSS nfet_06v0 ad=13.936p pd=54.12u as=13.936p ps=54.12u w=53.6u l=0.7u
X528 a_17764_160995# a_17764_160995# VSS VSS nfet_06v0 ad=13.936p pd=54.12u as=13.936p ps=54.12u w=53.6u l=0.7u
X529 a_17764_160995# a_17764_148611# a_17764_148611# VSS nfet_06v0 ad=13.936p pd=54.12u as=13.936p ps=54.12u w=53.6u l=0.7u
X530 a_17764_160995# a_17764_148611# a_17764_148611# VSS nfet_06v0 ad=13.936p pd=54.12u as=13.936p ps=54.12u w=53.6u l=0.7u
D12 PAD_N ESD_RAIL diode_pd2nw_06v0 pj=51.8u area=22.5p
X531 ESD_RAIL ESD_RAIL a_17764_148611# VSS nfet_06v0 ad=13.936p pd=54.12u as=13.936p ps=54.12u w=53.6u l=0.7u
X532 a_17764_148611# ESD_RAIL ESD_RAIL VSS nfet_06v0 ad=13.936p pd=54.12u as=13.936p ps=54.12u w=53.6u l=0.7u
X533 a_17764_148611# a_17764_148611# a_17764_160995# VSS nfet_06v0 ad=13.936p pd=54.12u as=13.936p ps=54.12u w=53.6u l=0.7u
X534 ESD_RAIL a_18245_90628# VSS VSS nfet_06v0 ad=13p pd=50.52u as=13p ps=50.52u w=50u l=0.7u
X535 BIAS_P_0 BIAS_P_1 VSS ppolyf_u_1k r_width=1u r_length=12.5u
X536 a_17764_148611# ESD_RAIL ESD_RAIL VSS nfet_06v0 ad=23.584p pd=0.10808m as=13.936p ps=54.12u w=53.6u l=0.7u
X537 a_17764_148611# a_17764_148611# a_17764_160995# VSS nfet_06v0 ad=13.936p pd=54.12u as=13.936p ps=54.12u w=53.6u l=0.7u
X538 a_17764_148611# a_17764_148611# a_17764_160995# VSS nfet_06v0 ad=13.936p pd=54.12u as=13.936p ps=54.12u w=53.6u l=0.7u
X539 a_17005_131825# a_29878_131545# ESD_RAIL ppolyf_u r_width=0.8u r_length=63.855u
X540 ESD_RAIL ESD_RAIL a_17764_148611# VSS nfet_06v0 ad=13.936p pd=54.12u as=13.936p ps=54.12u w=53.6u l=0.7u
X541 ESD_RAIL ESD_RAIL a_17764_148611# VSS nfet_06v0 ad=13.936p pd=54.12u as=23.584p ps=0.10808m w=53.6u l=0.7u
X542 VSS a_17764_160995# a_17764_160995# VSS nfet_06v0 ad=13.936p pd=54.12u as=13.936p ps=54.12u w=53.6u l=0.7u
X543 VSS a_17764_160995# a_17764_160995# VSS nfet_06v0 ad=13.936p pd=54.12u as=13.936p ps=54.12u w=53.6u l=0.7u
X544 a_17764_148611# a_17764_148611# a_17764_160995# VSS nfet_06v0 ad=13.936p pd=54.12u as=13.936p ps=54.12u w=53.6u l=0.7u
X545 ESD_RAIL a_20789_117064# a_18245_90628# ESD_RAIL pfet_06v0 ad=1.3p pd=5.52u as=1.3p ps=5.52u w=5u l=0.7u
X546 a_17764_148611# a_17764_148611# a_17764_160995# VSS nfet_06v0 ad=13.936p pd=54.12u as=13.936p ps=54.12u w=53.6u l=0.7u
X547 a_17764_160995# a_17764_148611# a_17764_148611# VSS nfet_06v0 ad=23.584p pd=0.10808m as=13.936p ps=54.12u w=53.6u l=0.7u
X548 a_17764_148611# a_17764_148611# a_17764_160995# VSS nfet_06v0 ad=13.936p pd=54.12u as=13.936p ps=54.12u w=53.6u l=0.7u
X549 a_17764_148611# ESD_RAIL ESD_RAIL VSS nfet_06v0 ad=13.936p pd=54.12u as=13.936p ps=54.12u w=53.6u l=0.7u
X550 a_17764_148611# ESD_RAIL ESD_RAIL VSS nfet_06v0 ad=13.936p pd=54.12u as=13.936p ps=54.12u w=53.6u l=0.7u
X551 a_17764_160995# a_17764_160995# VSS VSS nfet_06v0 ad=13.936p pd=54.12u as=13.936p ps=54.12u w=53.6u l=0.7u
X552 BIAS_P_5 BIAS_P_6 VSS ppolyf_u_1k r_width=1u r_length=12.5u
X553 ESD_RAIL ESD_RAIL a_17764_148611# VSS nfet_06v0 ad=13.936p pd=54.12u as=13.936p ps=54.12u w=53.6u l=0.7u
X554 a_17764_160995# a_17764_148611# a_17764_148611# VSS nfet_06v0 ad=13.936p pd=54.12u as=13.936p ps=54.12u w=53.6u l=0.7u
X555 ESD_RAIL ESD_RAIL a_17764_148611# VSS nfet_06v0 ad=13.936p pd=54.12u as=13.936p ps=54.12u w=53.6u l=0.7u
X556 VSS a_17764_160995# a_17764_160995# VSS nfet_06v0 ad=23.584p pd=0.10808m as=13.936p ps=54.12u w=53.6u l=0.7u
X557 VSS a_17764_160995# a_17764_160995# VSS nfet_06v0 ad=13.936p pd=54.12u as=13.936p ps=54.12u w=53.6u l=0.7u
X558 a_17764_148611# ESD_RAIL ESD_RAIL VSS nfet_06v0 ad=13.936p pd=54.12u as=13.936p ps=54.12u w=53.6u l=0.7u
X559 a_17764_148611# ESD_RAIL ESD_RAIL VSS nfet_06v0 ad=13.936p pd=54.12u as=13.936p ps=54.12u w=53.6u l=0.7u
X560 a_17764_148611# a_17764_148611# a_17764_160995# VSS nfet_06v0 ad=13.936p pd=54.12u as=13.936p ps=54.12u w=53.6u l=0.7u
X561 a_20789_117064# a_19813_117064# VSS VSS nfet_06v0 ad=1.3p pd=5.52u as=1.3p ps=5.52u w=5u l=0.7u
X562 a_17764_148611# ESD_RAIL ESD_RAIL VSS nfet_06v0 ad=13.936p pd=54.12u as=13.936p ps=54.12u w=53.6u l=0.7u
X563 a_17764_160995# a_17764_160995# VSS VSS nfet_06v0 ad=13.936p pd=54.12u as=23.584p ps=0.10808m w=53.6u l=0.7u
X564 a_17764_160995# a_17764_160995# VSS VSS nfet_06v0 ad=13.936p pd=54.12u as=13.936p ps=54.12u w=53.6u l=0.7u
X565 ESD_RAIL ESD_RAIL a_17764_148611# VSS nfet_06v0 ad=13.936p pd=54.12u as=23.584p ps=0.10808m w=53.6u l=0.7u
X566 ESD_RAIL ESD_RAIL a_17764_148611# VSS nfet_06v0 ad=13.936p pd=54.12u as=13.936p ps=54.12u w=53.6u l=0.7u
X567 ESD_RAIL ESD_RAIL a_17764_148611# VSS nfet_06v0 ad=13.936p pd=54.12u as=23.584p ps=0.10808m w=53.6u l=0.7u
X568 a_17764_160995# a_17764_148611# a_17764_148611# VSS nfet_06v0 ad=13.936p pd=54.12u as=13.936p ps=54.12u w=53.6u l=0.7u
X569 a_17764_160995# a_17764_148611# a_17764_148611# VSS nfet_06v0 ad=23.584p pd=0.10808m as=13.936p ps=54.12u w=53.6u l=0.7u
X570 VSS a_18245_90628# ESD_RAIL VSS nfet_06v0 ad=13p pd=50.52u as=13p ps=50.52u w=50u l=0.7u
X571 VSS a_17764_160995# a_17764_160995# VSS nfet_06v0 ad=13.936p pd=54.12u as=13.936p ps=54.12u w=53.6u l=0.7u
X572 a_17764_148611# a_17764_148611# a_17764_160995# VSS nfet_06v0 ad=13.936p pd=54.12u as=13.936p ps=54.12u w=53.6u l=0.7u
X573 a_17764_148611# ESD_RAIL ESD_RAIL VSS nfet_06v0 ad=13.936p pd=54.12u as=13.936p ps=54.12u w=53.6u l=0.7u
X574 a_17764_148611# ESD_RAIL ESD_RAIL VSS nfet_06v0 ad=13.936p pd=54.12u as=13.936p ps=54.12u w=53.6u l=0.7u
X575 a_17764_160995# a_17764_160995# VSS VSS nfet_06v0 ad=13.936p pd=54.12u as=13.936p ps=54.12u w=53.6u l=0.7u
X576 a_17005_132945# a_29878_132665# ESD_RAIL ppolyf_u r_width=0.8u r_length=63.855u
X577 a_17764_148611# ESD_RAIL ESD_RAIL VSS nfet_06v0 ad=13.936p pd=54.12u as=13.936p ps=54.12u w=53.6u l=0.7u
X578 VSS ESD_RAIL VSS ppolyf_u_1k_6p0 r_width=1u r_length=9.98874m
X579 a_17764_148611# ESD_RAIL ESD_RAIL VSS nfet_06v0 ad=23.584p pd=0.10808m as=13.936p ps=54.12u w=53.6u l=0.7u
X580 ESD_RAIL ESD_RAIL a_17764_148611# VSS nfet_06v0 ad=13.936p pd=54.12u as=13.936p ps=54.12u w=53.6u l=0.7u
X581 ESD_RAIL a_18245_90628# VSS VSS nfet_06v0 ad=13p pd=50.52u as=13p ps=50.52u w=50u l=0.7u
X582 ESD_RAIL ATB_ESD_RAIL VSS ppolyf_u_1k_6p0 r_width=1u r_length=0.47474m
X583 a_17764_160995# a_17764_148611# a_17764_148611# VSS nfet_06v0 ad=13.936p pd=54.12u as=13.936p ps=54.12u w=53.6u l=0.7u
X584 a_17764_148611# ESD_RAIL ESD_RAIL VSS nfet_06v0 ad=13.936p pd=54.12u as=13.936p ps=54.12u w=53.6u l=0.7u
X585 VSS a_17764_160995# a_17764_160995# VSS nfet_06v0 ad=13.936p pd=54.12u as=13.936p ps=54.12u w=53.6u l=0.7u
X586 BIAS_N_1 BIAS_N_2 VSS ppolyf_u_1k r_width=1u r_length=12.5u
X587 ESD_RAIL ESD_RAIL a_17764_148611# VSS nfet_06v0 ad=13.936p pd=54.12u as=13.936p ps=54.12u w=53.6u l=0.7u
X588 VSS a_17764_160995# a_17764_160995# VSS nfet_06v0 ad=13.936p pd=54.12u as=13.936p ps=54.12u w=53.6u l=0.7u
X589 a_17764_148611# a_17764_148611# a_17764_160995# VSS nfet_06v0 ad=13.936p pd=54.12u as=13.936p ps=54.12u w=53.6u l=0.7u
X590 VSS a_18245_90628# ESD_RAIL VSS nfet_06v0 ad=13p pd=50.52u as=13p ps=50.52u w=50u l=0.7u
X591 ESD_RAIL ESD_RAIL a_17764_148611# VSS nfet_06v0 ad=13.936p pd=54.12u as=23.584p ps=0.10808m w=53.6u l=0.7u
X592 a_17764_160995# a_17764_160995# VSS VSS nfet_06v0 ad=13.936p pd=54.12u as=13.936p ps=54.12u w=53.6u l=0.7u
X593 ESD_RAIL ESD_RAIL a_17764_148611# VSS nfet_06v0 ad=13.936p pd=54.12u as=13.936p ps=54.12u w=53.6u l=0.7u
X594 ESD_RAIL ESD_RAIL a_17764_148611# VSS nfet_06v0 ad=13.936p pd=54.12u as=23.584p ps=0.10808m w=53.6u l=0.7u
X595 VSS a_17764_160995# a_17764_160995# VSS nfet_06v0 ad=13.936p pd=54.12u as=13.936p ps=54.12u w=53.6u l=0.7u
X596 a_17764_160995# a_17764_160995# VSS VSS nfet_06v0 ad=13.936p pd=54.12u as=13.936p ps=54.12u w=53.6u l=0.7u
X597 a_17764_160995# a_17764_148611# a_17764_148611# VSS nfet_06v0 ad=23.584p pd=0.10808m as=13.936p ps=54.12u w=53.6u l=0.7u
X598 PAD_P BIAS_P_0 VSS ppolyf_u_1k r_width=1u r_length=12.5u
X599 a_17764_148611# ESD_RAIL ESD_RAIL VSS nfet_06v0 ad=23.584p pd=0.10808m as=13.936p ps=54.12u w=53.6u l=0.7u
X600 a_17764_160995# a_17764_160995# VSS VSS nfet_06v0 ad=13.936p pd=54.12u as=13.936p ps=54.12u w=53.6u l=0.7u
X601 a_17764_160995# a_17764_160995# VSS VSS nfet_06v0 ad=13.936p pd=54.12u as=13.936p ps=54.12u w=53.6u l=0.7u
X602 ESD_RAIL a_18245_90628# VSS VSS nfet_06v0 ad=13p pd=50.52u as=13p ps=50.52u w=50u l=0.7u
X603 a_18245_90628# a_20789_117064# ESD_RAIL ESD_RAIL pfet_06v0 ad=1.3p pd=5.52u as=1.3p ps=5.52u w=5u l=0.7u
X604 BIAS_N_3 BIAS_N_4 VSS ppolyf_u_1k r_width=1u r_length=12.5u
X605 BIAS_P_1 BIAS_P_2 VSS ppolyf_u_1k r_width=1u r_length=12.5u
X606 ESD_RAIL ESD_RAIL a_17764_148611# VSS nfet_06v0 ad=13.936p pd=54.12u as=13.936p ps=54.12u w=53.6u l=0.7u
X607 a_17764_160995# a_17764_160995# VSS VSS nfet_06v0 ad=13.936p pd=54.12u as=13.936p ps=54.12u w=53.6u l=0.7u
X608 a_17764_148611# ESD_RAIL ESD_RAIL VSS nfet_06v0 ad=13.936p pd=54.12u as=13.936p ps=54.12u w=53.6u l=0.7u
X609 VSS a_17764_160995# a_17764_160995# VSS nfet_06v0 ad=13.936p pd=54.12u as=13.936p ps=54.12u w=53.6u l=0.7u
X610 a_17764_148611# a_17764_148611# a_17764_160995# VSS nfet_06v0 ad=13.936p pd=54.12u as=13.936p ps=54.12u w=53.6u l=0.7u
X611 a_17764_148611# a_17764_148611# a_17764_160995# VSS nfet_06v0 ad=13.936p pd=54.12u as=13.936p ps=54.12u w=53.6u l=0.7u
X612 a_17764_148611# ESD_RAIL ESD_RAIL VSS nfet_06v0 ad=13.936p pd=54.12u as=13.936p ps=54.12u w=53.6u l=0.7u
X613 a_17764_160995# a_17764_160995# VSS VSS nfet_06v0 ad=13.936p pd=54.12u as=13.936p ps=54.12u w=53.6u l=0.7u
X614 ESD_RAIL ESD_RAIL a_17764_148611# VSS nfet_06v0 ad=13.936p pd=54.12u as=13.936p ps=54.12u w=53.6u l=0.7u
X615 ESD_RAIL ESD_RAIL a_17764_148611# VSS nfet_06v0 ad=13.936p pd=54.12u as=13.936p ps=54.12u w=53.6u l=0.7u
X616 VSS a_17764_160995# a_17764_160995# VSS nfet_06v0 ad=13.936p pd=54.12u as=13.936p ps=54.12u w=53.6u l=0.7u
D13 VSS PAD_N diode_nd2ps_06v0 pj=51.8u area=22.5p
X617 ESD_RAIL a_18245_90628# VSS VSS nfet_06v0 ad=13p pd=50.52u as=13p ps=50.52u w=50u l=0.7u
X618 ESD_RAIL a_20789_117064# a_18245_90628# ESD_RAIL pfet_06v0 ad=1.3p pd=5.52u as=1.3p ps=5.52u w=5u l=0.7u
X619 a_17764_148611# ESD_RAIL ESD_RAIL VSS nfet_06v0 ad=23.584p pd=0.10808m as=13.936p ps=54.12u w=53.6u l=0.7u
X620 VSS a_17764_160995# a_17764_160995# VSS nfet_06v0 ad=13.936p pd=54.12u as=13.936p ps=54.12u w=53.6u l=0.7u
D14 VSS PAD_N diode_nd2ps_06v0 pj=51.8u area=22.5p
X621 ESD_RAIL ESD_RAIL a_17764_148611# VSS nfet_06v0 ad=13.936p pd=54.12u as=13.936p ps=54.12u w=53.6u l=0.7u
X622 a_17764_160995# a_17764_160995# VSS VSS nfet_06v0 ad=13.936p pd=54.12u as=13.936p ps=54.12u w=53.6u l=0.7u
X623 a_17764_160995# a_17764_148611# a_17764_148611# VSS nfet_06v0 ad=13.936p pd=54.12u as=13.936p ps=54.12u w=53.6u l=0.7u
X624 a_17764_160995# a_17764_148611# a_17764_148611# VSS nfet_06v0 ad=13.936p pd=54.12u as=13.936p ps=54.12u w=53.6u l=0.7u
X625 ESD_RAIL ESD_RAIL a_17764_148611# VSS nfet_06v0 ad=13.936p pd=54.12u as=13.936p ps=54.12u w=53.6u l=0.7u
X626 ESD_RAIL ESD_RAIL a_17764_148611# VSS nfet_06v0 ad=13.936p pd=54.12u as=13.936p ps=54.12u w=53.6u l=0.7u
X627 VSS a_17764_160995# a_17764_160995# VSS nfet_06v0 ad=13.936p pd=54.12u as=13.936p ps=54.12u w=53.6u l=0.7u
X628 VSS a_18245_90628# ESD_RAIL VSS nfet_06v0 ad=13p pd=50.52u as=13p ps=50.52u w=50u l=0.7u
X629 ESD_RAIL ESD_RAIL a_17764_148611# VSS nfet_06v0 ad=13.936p pd=54.12u as=13.936p ps=54.12u w=53.6u l=0.7u
X630 a_17764_148611# a_17764_148611# a_17764_160995# VSS nfet_06v0 ad=13.936p pd=54.12u as=13.936p ps=54.12u w=53.6u l=0.7u
X631 a_17764_148611# ESD_RAIL ESD_RAIL VSS nfet_06v0 ad=13.936p pd=54.12u as=13.936p ps=54.12u w=53.6u l=0.7u
X632 ESD_RAIL ESD_RAIL a_17764_148611# VSS nfet_06v0 ad=13.936p pd=54.12u as=23.584p ps=0.10808m w=53.6u l=0.7u
D15 PAD_P ESD_RAIL diode_pd2nw_06v0 pj=51.8u area=22.5p
X633 a_17764_160995# a_17764_148611# a_17764_148611# VSS nfet_06v0 ad=13.936p pd=54.12u as=13.936p ps=54.12u w=53.6u l=0.7u
X634 VSS a_18245_90628# ESD_RAIL VSS nfet_06v0 ad=13p pd=50.52u as=13p ps=50.52u w=50u l=0.7u
X635 ESD_RAIL a_20789_117064# a_18245_90628# ESD_RAIL pfet_06v0 ad=2.2p pd=10.88u as=1.3p ps=5.52u w=5u l=0.7u
X636 a_17764_160995# a_17764_148611# a_17764_148611# VSS nfet_06v0 ad=23.584p pd=0.10808m as=13.936p ps=54.12u w=53.6u l=0.7u
X637 VSS a_18245_90628# ESD_RAIL VSS nfet_06v0 ad=13p pd=50.52u as=13p ps=50.52u w=50u l=0.7u
X638 ESD_RAIL ESD_RAIL a_17764_148611# VSS nfet_06v0 ad=13.936p pd=54.12u as=13.936p ps=54.12u w=53.6u l=0.7u
X639 a_17764_148611# ESD_RAIL ESD_RAIL VSS nfet_06v0 ad=13.936p pd=54.12u as=13.936p ps=54.12u w=53.6u l=0.7u
X640 a_17764_148611# ESD_RAIL ESD_RAIL VSS nfet_06v0 ad=23.584p pd=0.10808m as=13.936p ps=54.12u w=53.6u l=0.7u
X641 a_17005_134065# a_29878_133785# ESD_RAIL ppolyf_u r_width=0.8u r_length=63.855u
X642 a_17764_148611# a_17764_148611# a_17764_160995# VSS nfet_06v0 ad=13.936p pd=54.12u as=23.584p ps=0.10808m w=53.6u l=0.7u
X643 a_17764_148611# a_17764_148611# a_17764_160995# VSS nfet_06v0 ad=13.936p pd=54.12u as=13.936p ps=54.12u w=53.6u l=0.7u
X644 a_17764_148611# ESD_RAIL ESD_RAIL VSS nfet_06v0 ad=13.936p pd=54.12u as=13.936p ps=54.12u w=53.6u l=0.7u
X645 a_17764_148611# ESD_RAIL ESD_RAIL VSS nfet_06v0 ad=13.936p pd=54.12u as=13.936p ps=54.12u w=53.6u l=0.7u
X646 a_17764_160995# a_17764_160995# VSS VSS nfet_06v0 ad=13.936p pd=54.12u as=13.936p ps=54.12u w=53.6u l=0.7u
X647 a_17764_148611# ESD_RAIL ESD_RAIL VSS nfet_06v0 ad=13.936p pd=54.12u as=13.936p ps=54.12u w=53.6u l=0.7u
X648 a_17764_160995# a_17764_148611# a_17764_148611# VSS nfet_06v0 ad=13.936p pd=54.12u as=13.936p ps=54.12u w=53.6u l=0.7u
X649 VSS a_18245_90628# ESD_RAIL VSS nfet_06v0 ad=13p pd=50.52u as=13p ps=50.52u w=50u l=0.7u
X650 ESD_RAIL ESD_RAIL a_17764_148611# VSS nfet_06v0 ad=13.936p pd=54.12u as=13.936p ps=54.12u w=53.6u l=0.7u
X651 VSS a_17764_160995# a_17764_160995# VSS nfet_06v0 ad=13.936p pd=54.12u as=13.936p ps=54.12u w=53.6u l=0.7u
X652 VSS a_17764_160995# a_17764_160995# VSS nfet_06v0 ad=13.936p pd=54.12u as=13.936p ps=54.12u w=53.6u l=0.7u
X653 VSS a_17764_160995# a_17764_160995# VSS nfet_06v0 ad=13.936p pd=54.12u as=13.936p ps=54.12u w=53.6u l=0.7u
X654 a_17764_148611# a_17764_148611# a_17764_160995# VSS nfet_06v0 ad=13.936p pd=54.12u as=13.936p ps=54.12u w=53.6u l=0.7u
X655 VSS a_18245_90628# ESD_RAIL VSS nfet_06v0 ad=13p pd=50.52u as=13p ps=50.52u w=50u l=0.7u
X656 a_17764_148611# ESD_RAIL ESD_RAIL VSS nfet_06v0 ad=13.936p pd=54.12u as=13.936p ps=54.12u w=53.6u l=0.7u
X657 a_17764_148611# ESD_RAIL ESD_RAIL VSS nfet_06v0 ad=13.936p pd=54.12u as=13.936p ps=54.12u w=53.6u l=0.7u
D16 VSS ESD_RAIL diode_nd2ps_06v0 pj=82u area=40p
X658 ESD_RAIL ESD_RAIL a_17764_148611# VSS nfet_06v0 ad=13.936p pd=54.12u as=13.936p ps=54.12u w=53.6u l=0.7u
X659 a_17764_160995# a_17764_160995# VSS VSS nfet_06v0 ad=13.936p pd=54.12u as=13.936p ps=54.12u w=53.6u l=0.7u
X660 a_17764_148611# ESD_RAIL ESD_RAIL VSS nfet_06v0 ad=13.936p pd=54.12u as=13.936p ps=54.12u w=53.6u l=0.7u
X661 ESD_RAIL ESD_RAIL a_17764_148611# VSS nfet_06v0 ad=13.936p pd=54.12u as=13.936p ps=54.12u w=53.6u l=0.7u
X662 a_17764_160995# a_17764_160995# VSS VSS nfet_06v0 ad=13.936p pd=54.12u as=13.936p ps=54.12u w=53.6u l=0.7u
X663 a_17764_160995# a_17764_148611# a_17764_148611# VSS nfet_06v0 ad=13.936p pd=54.12u as=13.936p ps=54.12u w=53.6u l=0.7u
X664 a_17764_160995# a_17764_148611# a_17764_148611# VSS nfet_06v0 ad=13.936p pd=54.12u as=13.936p ps=54.12u w=53.6u l=0.7u
X665 VSS a_17764_160995# a_17764_160995# VSS nfet_06v0 ad=13.936p pd=54.12u as=13.936p ps=54.12u w=53.6u l=0.7u
X666 VSS a_17764_160995# a_17764_160995# VSS nfet_06v0 ad=13.936p pd=54.12u as=13.936p ps=54.12u w=53.6u l=0.7u
X667 a_17764_148611# ESD_RAIL ESD_RAIL VSS nfet_06v0 ad=13.936p pd=54.12u as=13.936p ps=54.12u w=53.6u l=0.7u
X668 a_17764_160995# a_17764_160995# VSS VSS nfet_06v0 ad=13.936p pd=54.12u as=13.936p ps=54.12u w=53.6u l=0.7u
X669 a_17764_148611# a_17764_148611# a_17764_160995# VSS nfet_06v0 ad=13.936p pd=54.12u as=13.936p ps=54.12u w=53.6u l=0.7u
X670 a_17764_148611# a_17764_148611# a_17764_160995# VSS nfet_06v0 ad=13.936p pd=54.12u as=13.936p ps=54.12u w=53.6u l=0.7u
X671 a_17764_160995# a_17764_148611# a_17764_148611# VSS nfet_06v0 ad=13.936p pd=54.12u as=13.936p ps=54.12u w=53.6u l=0.7u
X672 a_17764_160995# a_17764_160995# VSS VSS nfet_06v0 ad=13.936p pd=54.12u as=13.936p ps=54.12u w=53.6u l=0.7u
X673 ESD_RAIL ESD_RAIL a_17764_148611# VSS nfet_06v0 ad=13.936p pd=54.12u as=13.936p ps=54.12u w=53.6u l=0.7u
X674 ESD_RAIL ESD_RAIL a_17764_148611# VSS nfet_06v0 ad=13.936p pd=54.12u as=13.936p ps=54.12u w=53.6u l=0.7u
X675 ESD_RAIL a_17005_131545# a_19813_117064# ESD_RAIL pfet_06v0 ad=1.3p pd=5.52u as=1.3p ps=5.52u w=5u l=0.7u
X676 VSS a_17764_160995# a_17764_160995# VSS nfet_06v0 ad=13.936p pd=54.12u as=13.936p ps=54.12u w=53.6u l=0.7u
X677 VSS a_17764_160995# a_17764_160995# VSS nfet_06v0 ad=13.936p pd=54.12u as=13.936p ps=54.12u w=53.6u l=0.7u
X678 a_17764_148611# a_17764_148611# a_17764_160995# VSS nfet_06v0 ad=13.936p pd=54.12u as=13.936p ps=54.12u w=53.6u l=0.7u
X679 a_17764_148611# a_17764_148611# a_17764_160995# VSS nfet_06v0 ad=13.936p pd=54.12u as=13.936p ps=54.12u w=53.6u l=0.7u
X680 a_17764_148611# ESD_RAIL ESD_RAIL VSS nfet_06v0 ad=13.936p pd=54.12u as=13.936p ps=54.12u w=53.6u l=0.7u
X681 a_17764_160995# a_17764_160995# VSS VSS nfet_06v0 ad=13.936p pd=54.12u as=13.936p ps=54.12u w=53.6u l=0.7u
X682 VSS a_17764_160995# a_17764_160995# VSS nfet_06v0 ad=13.936p pd=54.12u as=13.936p ps=54.12u w=53.6u l=0.7u
X683 a_19813_117064# a_17005_131545# ESD_RAIL ESD_RAIL pfet_06v0 ad=1.3p pd=5.52u as=2.2p ps=10.88u w=5u l=0.7u
X684 ESD_RAIL ESD_RAIL a_17764_148611# VSS nfet_06v0 ad=13.936p pd=54.12u as=13.936p ps=54.12u w=53.6u l=0.7u
X685 VSS a_17764_160995# a_17764_160995# VSS nfet_06v0 ad=13.936p pd=54.12u as=13.936p ps=54.12u w=53.6u l=0.7u
X686 ESD_RAIL a_18245_90628# VSS VSS nfet_06v0 ad=22p pd=0.10088m as=13p ps=50.52u w=50u l=0.7u
X687 a_17764_148611# a_17764_148611# a_17764_160995# VSS nfet_06v0 ad=13.936p pd=54.12u as=13.936p ps=54.12u w=53.6u l=0.7u
X688 a_17764_160995# a_17764_160995# VSS VSS nfet_06v0 ad=13.936p pd=54.12u as=13.936p ps=54.12u w=53.6u l=0.7u
X689 ESD_RAIL ESD_RAIL a_17764_148611# VSS nfet_06v0 ad=13.936p pd=54.12u as=13.936p ps=54.12u w=53.6u l=0.7u
X690 VSS a_17764_160995# a_17764_160995# VSS nfet_06v0 ad=13.936p pd=54.12u as=13.936p ps=54.12u w=53.6u l=0.7u
X691 ESD_RAIL a_18245_90628# VSS VSS nfet_06v0 ad=13p pd=50.52u as=13p ps=50.52u w=50u l=0.7u
X692 a_17764_160995# a_17764_148611# a_17764_148611# VSS nfet_06v0 ad=13.936p pd=54.12u as=13.936p ps=54.12u w=53.6u l=0.7u
X693 a_17764_148611# ESD_RAIL ESD_RAIL VSS nfet_06v0 ad=13.936p pd=54.12u as=13.936p ps=54.12u w=53.6u l=0.7u
X694 VSS a_17764_160995# a_17764_160995# VSS nfet_06v0 ad=13.936p pd=54.12u as=13.936p ps=54.12u w=53.6u l=0.7u
X695 a_17764_148611# a_17764_148611# a_17764_160995# VSS nfet_06v0 ad=13.936p pd=54.12u as=13.936p ps=54.12u w=53.6u l=0.7u
X696 a_17764_160995# a_17764_160995# VSS VSS nfet_06v0 ad=13.936p pd=54.12u as=23.584p ps=0.10808m w=53.6u l=0.7u
X697 VSS a_18245_90628# ESD_RAIL VSS nfet_06v0 ad=13p pd=50.52u as=13p ps=50.52u w=50u l=0.7u
X698 a_17764_148611# ESD_RAIL ESD_RAIL VSS nfet_06v0 ad=13.936p pd=54.12u as=13.936p ps=54.12u w=53.6u l=0.7u
X699 a_17764_160995# a_17764_160995# VSS VSS nfet_06v0 ad=13.936p pd=54.12u as=23.584p ps=0.10808m w=53.6u l=0.7u
X700 a_17764_160995# a_17764_160995# VSS VSS nfet_06v0 ad=13.936p pd=54.12u as=13.936p ps=54.12u w=53.6u l=0.7u
X701 a_17764_160995# a_17764_148611# a_17764_148611# VSS nfet_06v0 ad=13.936p pd=54.12u as=13.936p ps=54.12u w=53.6u l=0.7u
X702 ESD_RAIL ESD_RAIL a_17764_148611# VSS nfet_06v0 ad=13.936p pd=54.12u as=13.936p ps=54.12u w=53.6u l=0.7u
X703 ESD_RAIL ESD_RAIL a_17764_148611# VSS nfet_06v0 ad=13.936p pd=54.12u as=13.936p ps=54.12u w=53.6u l=0.7u
X704 a_17764_160995# a_17764_148611# a_17764_148611# VSS nfet_06v0 ad=13.936p pd=54.12u as=13.936p ps=54.12u w=53.6u l=0.7u
X705 VSS a_17764_160995# a_17764_160995# VSS nfet_06v0 ad=13.936p pd=54.12u as=13.936p ps=54.12u w=53.6u l=0.7u
X706 ESD_RAIL a_18245_90628# VSS VSS nfet_06v0 ad=22p pd=0.10088m as=13p ps=50.52u w=50u l=0.7u
X707 a_17764_148611# ESD_RAIL ESD_RAIL VSS nfet_06v0 ad=13.936p pd=54.12u as=13.936p ps=54.12u w=53.6u l=0.7u
X708 a_17764_148611# a_17764_148611# a_17764_160995# VSS nfet_06v0 ad=13.936p pd=54.12u as=13.936p ps=54.12u w=53.6u l=0.7u
X709 a_17764_148611# ESD_RAIL ESD_RAIL VSS nfet_06v0 ad=13.936p pd=54.12u as=13.936p ps=54.12u w=53.6u l=0.7u
X710 a_17764_160995# a_17764_160995# VSS VSS nfet_06v0 ad=13.936p pd=54.12u as=13.936p ps=54.12u w=53.6u l=0.7u
D17 VSS PAD_P diode_nd2ps_06v0 pj=51.8u area=22.5p
X711 a_17764_148611# ESD_RAIL ESD_RAIL VSS nfet_06v0 ad=23.584p pd=0.10808m as=13.936p ps=54.12u w=53.6u l=0.7u
X712 a_17764_160995# a_17764_160995# VSS VSS nfet_06v0 ad=13.936p pd=54.12u as=13.936p ps=54.12u w=53.6u l=0.7u
X713 a_17764_160995# a_17764_148611# a_17764_148611# VSS nfet_06v0 ad=13.936p pd=54.12u as=13.936p ps=54.12u w=53.6u l=0.7u
X714 VSS a_17764_160995# a_17764_160995# VSS nfet_06v0 ad=13.936p pd=54.12u as=13.936p ps=54.12u w=53.6u l=0.7u
X715 a_17764_148611# ESD_RAIL ESD_RAIL VSS nfet_06v0 ad=13.936p pd=54.12u as=13.936p ps=54.12u w=53.6u l=0.7u
X716 VSS a_17764_160995# a_17764_160995# VSS nfet_06v0 ad=13.936p pd=54.12u as=13.936p ps=54.12u w=53.6u l=0.7u
X717 VSS a_18245_90628# ESD_RAIL VSS nfet_06v0 ad=13p pd=50.52u as=13p ps=50.52u w=50u l=0.7u
X718 VSS a_18245_90628# ESD_RAIL VSS nfet_06v0 ad=13p pd=50.52u as=22p ps=0.10088m w=50u l=0.7u
X719 ESD_RAIL a_20789_117064# a_18245_90628# ESD_RAIL pfet_06v0 ad=1.3p pd=5.52u as=1.3p ps=5.52u w=5u l=0.7u
X720 a_18245_90628# a_20789_117064# ESD_RAIL ESD_RAIL pfet_06v0 ad=1.3p pd=5.52u as=1.3p ps=5.52u w=5u l=0.7u
X721 ESD_RAIL ESD_RAIL a_17764_148611# VSS nfet_06v0 ad=13.936p pd=54.12u as=13.936p ps=54.12u w=53.6u l=0.7u
X722 VSS a_17764_160995# a_17764_160995# VSS nfet_06v0 ad=13.936p pd=54.12u as=13.936p ps=54.12u w=53.6u l=0.7u
X723 VSS a_18245_90628# ESD_RAIL VSS nfet_06v0 ad=13p pd=50.52u as=13p ps=50.52u w=50u l=0.7u
X724 VSS a_17764_160995# a_17764_160995# VSS nfet_06v0 ad=13.936p pd=54.12u as=13.936p ps=54.12u w=53.6u l=0.7u
X725 ESD_RAIL ESD_RAIL a_17764_148611# VSS nfet_06v0 ad=13.936p pd=54.12u as=13.936p ps=54.12u w=53.6u l=0.7u
X726 a_17764_148611# a_17764_148611# a_17764_160995# VSS nfet_06v0 ad=13.936p pd=54.12u as=13.936p ps=54.12u w=53.6u l=0.7u
X727 a_17764_160995# a_17764_160995# VSS VSS nfet_06v0 ad=13.936p pd=54.12u as=13.936p ps=54.12u w=53.6u l=0.7u
X728 a_17764_148611# ESD_RAIL ESD_RAIL VSS nfet_06v0 ad=23.584p pd=0.10808m as=13.936p ps=54.12u w=53.6u l=0.7u
X729 ESD_RAIL a_18245_90628# VSS VSS nfet_06v0 ad=13p pd=50.52u as=13p ps=50.52u w=50u l=0.7u
X730 a_17764_160995# a_17764_148611# a_17764_148611# VSS nfet_06v0 ad=13.936p pd=54.12u as=13.936p ps=54.12u w=53.6u l=0.7u
X731 ESD_RAIL ESD_RAIL a_17764_148611# VSS nfet_06v0 ad=13.936p pd=54.12u as=13.936p ps=54.12u w=53.6u l=0.7u
X732 a_17764_160995# a_17764_160995# VSS VSS nfet_06v0 ad=13.936p pd=54.12u as=13.936p ps=54.12u w=53.6u l=0.7u
X733 a_17764_160995# a_17764_148611# a_17764_148611# VSS nfet_06v0 ad=13.936p pd=54.12u as=13.936p ps=54.12u w=53.6u l=0.7u
X734 a_17764_160995# a_17764_148611# a_17764_148611# VSS nfet_06v0 ad=13.936p pd=54.12u as=13.936p ps=54.12u w=53.6u l=0.7u
X735 ESD_RAIL ESD_RAIL a_17764_148611# VSS nfet_06v0 ad=13.936p pd=54.12u as=13.936p ps=54.12u w=53.6u l=0.7u
X736 VSS a_17764_160995# a_17764_160995# VSS nfet_06v0 ad=13.936p pd=54.12u as=13.936p ps=54.12u w=53.6u l=0.7u
X737 a_17764_160995# a_17764_160995# VSS VSS nfet_06v0 ad=13.936p pd=54.12u as=13.936p ps=54.12u w=53.6u l=0.7u
X738 a_18245_90628# a_20789_117064# ESD_RAIL ESD_RAIL pfet_06v0 ad=1.3p pd=5.52u as=1.3p ps=5.52u w=5u l=0.7u
X739 VSS a_18245_90628# ESD_RAIL VSS nfet_06v0 ad=13p pd=50.52u as=13p ps=50.52u w=50u l=0.7u
X740 ESD_RAIL a_20789_117064# a_18245_90628# ESD_RAIL pfet_06v0 ad=1.3p pd=5.52u as=1.3p ps=5.52u w=5u l=0.7u
X741 a_17764_148611# ESD_RAIL ESD_RAIL VSS nfet_06v0 ad=13.936p pd=54.12u as=13.936p ps=54.12u w=53.6u l=0.7u
X742 a_17764_160995# a_17764_160995# VSS VSS nfet_06v0 ad=13.936p pd=54.12u as=23.584p ps=0.10808m w=53.6u l=0.7u
X743 a_17764_148611# ESD_RAIL ESD_RAIL VSS nfet_06v0 ad=13.936p pd=54.12u as=13.936p ps=54.12u w=53.6u l=0.7u
X744 a_17764_148611# a_17764_148611# a_17764_160995# VSS nfet_06v0 ad=13.936p pd=54.12u as=13.936p ps=54.12u w=53.6u l=0.7u
X745 a_17764_160995# a_17764_160995# VSS VSS nfet_06v0 ad=13.936p pd=54.12u as=13.936p ps=54.12u w=53.6u l=0.7u
X746 a_17764_148611# a_17764_148611# a_17764_160995# VSS nfet_06v0 ad=13.936p pd=54.12u as=13.936p ps=54.12u w=53.6u l=0.7u
X747 ESD_RAIL ESD_RAIL a_17764_148611# VSS nfet_06v0 ad=13.936p pd=54.12u as=13.936p ps=54.12u w=53.6u l=0.7u
X748 ESD_RAIL a_18245_90628# VSS VSS nfet_06v0 ad=13p pd=50.52u as=13p ps=50.52u w=50u l=0.7u
X749 ESD_RAIL ESD_RAIL a_17764_148611# VSS nfet_06v0 ad=13.936p pd=54.12u as=13.936p ps=54.12u w=53.6u l=0.7u
X750 a_17764_160995# a_17764_160995# VSS VSS nfet_06v0 ad=13.936p pd=54.12u as=13.936p ps=54.12u w=53.6u l=0.7u
X751 a_17764_160995# a_17764_148611# a_17764_148611# VSS nfet_06v0 ad=13.936p pd=54.12u as=13.936p ps=54.12u w=53.6u l=0.7u
X752 a_17764_160995# a_17764_148611# a_17764_148611# VSS nfet_06v0 ad=13.936p pd=54.12u as=13.936p ps=54.12u w=53.6u l=0.7u
X753 VSS a_17764_160995# a_17764_160995# VSS nfet_06v0 ad=13.936p pd=54.12u as=13.936p ps=54.12u w=53.6u l=0.7u
X754 a_17764_148611# a_17764_148611# a_17764_160995# VSS nfet_06v0 ad=13.936p pd=54.12u as=13.936p ps=54.12u w=53.6u l=0.7u
X755 ESD_RAIL ESD_RAIL a_17764_148611# VSS nfet_06v0 ad=13.936p pd=54.12u as=13.936p ps=54.12u w=53.6u l=0.7u
X756 a_17764_148611# ESD_RAIL ESD_RAIL VSS nfet_06v0 ad=13.936p pd=54.12u as=13.936p ps=54.12u w=53.6u l=0.7u
X757 VSS a_17764_160995# a_17764_160995# VSS nfet_06v0 ad=13.936p pd=54.12u as=13.936p ps=54.12u w=53.6u l=0.7u
X758 a_17764_148611# ESD_RAIL ESD_RAIL VSS nfet_06v0 ad=23.584p pd=0.10808m as=13.936p ps=54.12u w=53.6u l=0.7u
X759 a_17764_148611# ESD_RAIL ESD_RAIL VSS nfet_06v0 ad=13.936p pd=54.12u as=13.936p ps=54.12u w=53.6u l=0.7u
X760 a_17764_148611# a_17764_148611# a_17764_160995# VSS nfet_06v0 ad=13.936p pd=54.12u as=13.936p ps=54.12u w=53.6u l=0.7u
X761 a_18245_90628# a_20789_117064# VSS VSS nfet_06v0 ad=1.3p pd=5.52u as=1.3p ps=5.52u w=5u l=0.7u
X762 ESD_RAIL a_20789_117064# a_18245_90628# ESD_RAIL pfet_06v0 ad=1.3p pd=5.52u as=1.3p ps=5.52u w=5u l=0.7u
X763 a_18245_90628# a_20789_117064# ESD_RAIL ESD_RAIL pfet_06v0 ad=1.3p pd=5.52u as=1.3p ps=5.52u w=5u l=0.7u
X764 BIAS_N_6 VCM VSS ppolyf_u_1k r_width=1u r_length=12.5u
X765 a_17764_160995# a_17764_160995# VSS VSS nfet_06v0 ad=13.936p pd=54.12u as=13.936p ps=54.12u w=53.6u l=0.7u
X766 a_17764_160995# a_17764_160995# VSS VSS nfet_06v0 ad=13.936p pd=54.12u as=13.936p ps=54.12u w=53.6u l=0.7u
X767 BIAS_P_4 BIAS_P_5 VSS ppolyf_u_1k r_width=1u r_length=12.5u
X768 a_17764_160995# a_17764_148611# a_17764_148611# VSS nfet_06v0 ad=13.936p pd=54.12u as=13.936p ps=54.12u w=53.6u l=0.7u
X769 a_17764_160995# a_17764_148611# a_17764_148611# VSS nfet_06v0 ad=13.936p pd=54.12u as=13.936p ps=54.12u w=53.6u l=0.7u
X770 VSS a_17764_160995# a_17764_160995# VSS nfet_06v0 ad=13.936p pd=54.12u as=13.936p ps=54.12u w=53.6u l=0.7u
X771 a_17764_148611# a_17764_148611# a_17764_160995# VSS nfet_06v0 ad=13.936p pd=54.12u as=13.936p ps=54.12u w=53.6u l=0.7u
X772 a_17764_160995# a_17764_148611# a_17764_148611# VSS nfet_06v0 ad=13.936p pd=54.12u as=13.936p ps=54.12u w=53.6u l=0.7u
X773 ESD_RAIL ESD_RAIL a_17764_148611# VSS nfet_06v0 ad=13.936p pd=54.12u as=13.936p ps=54.12u w=53.6u l=0.7u
X774 BIAS_N_0 BIAS_N_1 VSS ppolyf_u_1k r_width=1u r_length=12.5u
X775 VSS a_17764_160995# a_17764_160995# VSS nfet_06v0 ad=13.936p pd=54.12u as=13.936p ps=54.12u w=53.6u l=0.7u
X776 VSS a_18245_90628# ESD_RAIL VSS nfet_06v0 ad=13p pd=50.52u as=13p ps=50.52u w=50u l=0.7u
X777 a_17764_160995# a_17764_148611# a_17764_148611# VSS nfet_06v0 ad=13.936p pd=54.12u as=13.936p ps=54.12u w=53.6u l=0.7u
X778 ESD_RAIL ESD_RAIL a_17764_148611# VSS nfet_06v0 ad=13.936p pd=54.12u as=23.584p ps=0.10808m w=53.6u l=0.7u
X779 VSS a_17764_160995# a_17764_160995# VSS nfet_06v0 ad=13.936p pd=54.12u as=13.936p ps=54.12u w=53.6u l=0.7u
X780 VSS a_17764_160995# a_17764_160995# VSS nfet_06v0 ad=13.936p pd=54.12u as=13.936p ps=54.12u w=53.6u l=0.7u
X781 a_17764_148611# a_17764_148611# a_17764_160995# VSS nfet_06v0 ad=13.936p pd=54.12u as=13.936p ps=54.12u w=53.6u l=0.7u
X782 a_17764_160995# a_17764_148611# a_17764_148611# VSS nfet_06v0 ad=13.936p pd=54.12u as=13.936p ps=54.12u w=53.6u l=0.7u
X783 ESD_RAIL ESD_RAIL a_17764_148611# VSS nfet_06v0 ad=13.936p pd=54.12u as=13.936p ps=54.12u w=53.6u l=0.7u
X784 ESD_RAIL ESD_RAIL a_17764_148611# VSS nfet_06v0 ad=13.936p pd=54.12u as=13.936p ps=54.12u w=53.6u l=0.7u
X785 ESD_RAIL ESD_RAIL a_17764_148611# VSS nfet_06v0 ad=13.936p pd=54.12u as=13.936p ps=54.12u w=53.6u l=0.7u
X786 a_17764_160995# a_17764_148611# a_17764_148611# VSS nfet_06v0 ad=13.936p pd=54.12u as=13.936p ps=54.12u w=53.6u l=0.7u
X787 a_18245_90628# a_20789_117064# ESD_RAIL ESD_RAIL pfet_06v0 ad=1.3p pd=5.52u as=1.3p ps=5.52u w=5u l=0.7u
X788 ESD_RAIL a_18245_90628# VSS VSS nfet_06v0 ad=13p pd=50.52u as=13p ps=50.52u w=50u l=0.7u
X789 VSS a_17764_160995# a_17764_160995# VSS nfet_06v0 ad=13.936p pd=54.12u as=13.936p ps=54.12u w=53.6u l=0.7u
X790 a_17764_148611# a_17764_148611# a_17764_160995# VSS nfet_06v0 ad=13.936p pd=54.12u as=23.584p ps=0.10808m w=53.6u l=0.7u
X791 a_17764_148611# a_17764_148611# a_17764_160995# VSS nfet_06v0 ad=13.936p pd=54.12u as=23.584p ps=0.10808m w=53.6u l=0.7u
X792 a_17764_148611# a_17764_148611# a_17764_160995# VSS nfet_06v0 ad=13.936p pd=54.12u as=13.936p ps=54.12u w=53.6u l=0.7u
X793 a_17764_148611# ESD_RAIL ESD_RAIL VSS nfet_06v0 ad=13.936p pd=54.12u as=13.936p ps=54.12u w=53.6u l=0.7u
X794 a_17764_148611# ESD_RAIL ESD_RAIL VSS nfet_06v0 ad=13.936p pd=54.12u as=13.936p ps=54.12u w=53.6u l=0.7u
X795 a_17764_160995# a_17764_160995# VSS VSS nfet_06v0 ad=13.936p pd=54.12u as=13.936p ps=54.12u w=53.6u l=0.7u
X796 ESD_RAIL ESD_RAIL a_17764_148611# VSS nfet_06v0 ad=13.936p pd=54.12u as=13.936p ps=54.12u w=53.6u l=0.7u
X797 a_17764_148611# ESD_RAIL ESD_RAIL VSS nfet_06v0 ad=13.936p pd=54.12u as=13.936p ps=54.12u w=53.6u l=0.7u
X798 a_17005_131545# a_29878_131545# ESD_RAIL ppolyf_u r_width=0.8u r_length=63.855u
X799 a_17764_160995# a_17764_160995# VSS VSS nfet_06v0 ad=13.936p pd=54.12u as=13.936p ps=54.12u w=53.6u l=0.7u
X800 a_17764_160995# a_17764_148611# a_17764_148611# VSS nfet_06v0 ad=13.936p pd=54.12u as=13.936p ps=54.12u w=53.6u l=0.7u
X801 VSS a_18245_90628# ESD_RAIL VSS nfet_06v0 ad=13p pd=50.52u as=13p ps=50.52u w=50u l=0.7u
X802 VSS a_17764_160995# a_17764_160995# VSS nfet_06v0 ad=13.936p pd=54.12u as=13.936p ps=54.12u w=53.6u l=0.7u
X803 a_17764_160995# a_17764_160995# VSS VSS nfet_06v0 ad=13.936p pd=54.12u as=23.584p ps=0.10808m w=53.6u l=0.7u
X804 VSS a_17764_160995# a_17764_160995# VSS nfet_06v0 ad=13.936p pd=54.12u as=13.936p ps=54.12u w=53.6u l=0.7u
X805 a_17764_160995# a_17764_160995# VSS VSS nfet_06v0 ad=13.936p pd=54.12u as=13.936p ps=54.12u w=53.6u l=0.7u
X806 VSS a_17764_160995# a_17764_160995# VSS nfet_06v0 ad=13.936p pd=54.12u as=13.936p ps=54.12u w=53.6u l=0.7u
D18 PAD_N ESD_RAIL diode_pd2nw_06v0 pj=51.8u area=22.5p
X807 VSS a_17764_160995# a_17764_160995# VSS nfet_06v0 ad=13.936p pd=54.12u as=13.936p ps=54.12u w=53.6u l=0.7u
X808 a_17764_148611# a_17764_148611# a_17764_160995# VSS nfet_06v0 ad=13.936p pd=54.12u as=13.936p ps=54.12u w=53.6u l=0.7u
X809 a_17764_148611# a_17764_148611# a_17764_160995# VSS nfet_06v0 ad=13.936p pd=54.12u as=13.936p ps=54.12u w=53.6u l=0.7u
X810 ESD_RAIL a_18245_90628# VSS VSS nfet_06v0 ad=13p pd=50.52u as=13p ps=50.52u w=50u l=0.7u
X811 a_17764_160995# a_17764_160995# VSS VSS nfet_06v0 ad=13.936p pd=54.12u as=13.936p ps=54.12u w=53.6u l=0.7u
D19 PAD_N ESD_RAIL diode_pd2nw_06v0 pj=51.8u area=22.5p
X812 a_17764_160995# a_17764_148611# a_17764_148611# VSS nfet_06v0 ad=13.936p pd=54.12u as=13.936p ps=54.12u w=53.6u l=0.7u
X813 ESD_RAIL ESD_RAIL a_17764_148611# VSS nfet_06v0 ad=13.936p pd=54.12u as=13.936p ps=54.12u w=53.6u l=0.7u
X814 ESD_RAIL ESD_RAIL a_17764_148611# VSS nfet_06v0 ad=13.936p pd=54.12u as=13.936p ps=54.12u w=53.6u l=0.7u
X815 a_17764_148611# ESD_RAIL ESD_RAIL VSS nfet_06v0 ad=13.936p pd=54.12u as=13.936p ps=54.12u w=53.6u l=0.7u
X816 VSS a_17764_160995# a_17764_160995# VSS nfet_06v0 ad=13.936p pd=54.12u as=13.936p ps=54.12u w=53.6u l=0.7u
X817 a_17764_160995# a_17764_148611# a_17764_148611# VSS nfet_06v0 ad=13.936p pd=54.12u as=13.936p ps=54.12u w=53.6u l=0.7u
X818 VSS a_18245_90628# ESD_RAIL VSS nfet_06v0 ad=13p pd=50.52u as=13p ps=50.52u w=50u l=0.7u
X819 a_17764_148611# ESD_RAIL ESD_RAIL VSS nfet_06v0 ad=13.936p pd=54.12u as=13.936p ps=54.12u w=53.6u l=0.7u
X820 PAD_N BIAS_N_0 VSS ppolyf_u_1k r_width=1u r_length=12.5u
X821 a_17764_148611# ESD_RAIL ESD_RAIL VSS nfet_06v0 ad=13.936p pd=54.12u as=13.936p ps=54.12u w=53.6u l=0.7u
X822 a_17764_160995# a_17764_160995# VSS VSS nfet_06v0 ad=13.936p pd=54.12u as=13.936p ps=54.12u w=53.6u l=0.7u
X823 a_17764_160995# a_17764_160995# VSS VSS nfet_06v0 ad=13.936p pd=54.12u as=13.936p ps=54.12u w=53.6u l=0.7u
X824 a_17764_160995# a_17764_148611# a_17764_148611# VSS nfet_06v0 ad=13.936p pd=54.12u as=13.936p ps=54.12u w=53.6u l=0.7u
X825 a_18245_90628# a_20789_117064# ESD_RAIL ESD_RAIL pfet_06v0 ad=1.3p pd=5.52u as=1.3p ps=5.52u w=5u l=0.7u
X826 a_17764_160995# a_17764_148611# a_17764_148611# VSS nfet_06v0 ad=13.936p pd=54.12u as=13.936p ps=54.12u w=53.6u l=0.7u
X827 VSS a_18245_90628# ESD_RAIL VSS nfet_06v0 ad=13p pd=50.52u as=13p ps=50.52u w=50u l=0.7u
X828 ESD_RAIL ESD_RAIL a_17764_148611# VSS nfet_06v0 ad=13.936p pd=54.12u as=13.936p ps=54.12u w=53.6u l=0.7u
C0 PAD_N ESD_RAIL 23.0912f
C1 BIAS_N_5 BIAS_N_6 3.55176f
C2 a_19813_117064# ESD_RAIL 4.89902f
C3 BIAS_P_3 BIAS_P_1 0.00832f
C4 BIAS_N_3 BIAS_N_1 0.0653f
C5 BIAS_P_4 BIAS_N_1 0.00103f
C6 BIAS_N_2 PAD_P 0.39538f
C7 BIAS_N_2 PAD_N 0.41491f
C8 PAD_N ATB_ESD_RAIL 0.02943f
C9 a_29878_133225# a_29878_133785# 0.0346f
C10 BIAS_N_4 BIAS_N_6 0.0653f
C11 BIAS_P_6 VCM 1.99081f
C12 BIAS_P_1 BIAS_P_4 0.034f
C13 a_17005_131825# m2_18279_124800# 0
C14 VCM PAD_P 47.7261f
C15 PAD_N VCM 0.25024f
C16 m2_18279_124800# a_17005_131545# 0.05457f
C17 a_19813_117064# a_20789_117064# 2.94235f
C18 a_17005_131825# a_17005_131545# 0.03725f
C19 ESD_RAIL m2_18279_124800# 5.47988f
C20 PAD_N BIAS_N_0 0.46444f
C21 VCM BIAS_N_5 0.0755f
C22 a_17005_132385# m2_18279_124800# 0
C23 ESD_RAIL a_17005_131825# 0.53823f
C24 BIAS_P_3 PAD_P 0.40676f
C25 ESD_RAIL a_17005_131545# 96.5489f
C26 a_17005_132945# a_17005_133505# 0.0346f
C27 a_17005_131825# a_17005_132385# 0.0346f
C28 PAD_N BIAS_P_3 0.50239f
C29 BIAS_N_4 VCM 0.05163f
C30 BIAS_P_6 BIAS_P_4 0.00228f
C31 a_17005_132385# a_17005_131545# 0
C32 a_19813_117064# a_18245_90628# 0.00994f
C33 ESD_RAIL a_29878_134345# 0.5677f
C34 a_17005_134065# a_17005_133505# 0.0346f
C35 BIAS_N_3 PAD_P 0.23379f
C36 BIAS_P_4 PAD_P 0.23948f
C37 PAD_N BIAS_N_3 0.2554f
C38 PAD_N BIAS_P_4 1.00207f
C39 ESD_RAIL a_17005_132385# 0.53823f
C40 BIAS_N_4 BIAS_N_0 0.00103f
C41 PAD_P BIAS_N_1 0.23321f
C42 PAD_N BIAS_N_1 0.1947f
C43 VCM BIAS_N_6 0.17957f
C44 a_20789_117064# a_17005_131545# 0.02879f
C45 a_29878_132105# a_29878_131545# 0.0346f
C46 BIAS_P_5 VCM 0.07484f
C47 ESD_RAIL a_29878_132665# 0.53916f
C48 BIAS_N_3 BIAS_N_5 0.11974f
C49 BIAS_P_1 PAD_P 0.30166f
C50 BIAS_N_0 BIAS_P_0 0.20954f
C51 PAD_N BIAS_P_1 0.70669f
C52 ESD_RAIL a_20789_117064# 13.9519f
C53 BIAS_N_4 BIAS_N_3 0.6241f
C54 BIAS_P_3 BIAS_P_2 1.71751f
C55 BIAS_N_2 VCM 0.0755f
C56 a_17005_133505# m2_18279_124800# 0
C57 a_18245_90628# a_17005_131545# 0.0135f
C58 BIAS_P_4 BIAS_P_2 0.06278f
C59 ESD_RAIL a_18245_90628# 0.24367p
C60 BIAS_N_2 BIAS_N_0 0.11843f
C61 BIAS_N_3 BIAS_N_6 0.13175f
C62 BIAS_P_5 BIAS_P_4 0.47572f
C63 BIAS_P_6 PAD_P 0.5037f
C64 a_29878_133785# a_29878_134345# 0.0346f
C65 a_29878_133785# ESD_RAIL 0.53942f
C66 BIAS_P_6 PAD_N 0.93458f
C67 ESD_RAIL a_17005_133505# 0.53842f
C68 PAD_N PAD_P 73.46249f
C69 BIAS_P_1 BIAS_P_2 0.27824f
C70 BIAS_P_1 BIAS_P_0 3.39678f
C71 BIAS_P_5 BIAS_P_1 0
C72 a_20789_117064# a_18245_90628# 10.1844f
C73 BIAS_N_2 BIAS_N_3 3.78393f
C74 PAD_P BIAS_N_5 0.39538f
C75 PAD_N BIAS_N_5 0.41491f
C76 a_29878_133225# ESD_RAIL 0.53916f
C77 BIAS_N_2 BIAS_N_1 2.38477f
C78 ESD_RAIL a_29878_132105# 0.53942f
C79 BIAS_N_3 VCM 0.04195f
C80 a_17005_132945# m2_18279_124800# 0
C81 BIAS_N_4 PAD_P 0.23321f
C82 a_17764_160995# a_17764_148611# 1.23933p
C83 PAD_N BIAS_N_4 0.1947f
C84 VCM BIAS_N_1 0.05163f
C85 BIAS_N_0 BIAS_N_3 0.09904f
C86 a_29878_133225# a_29878_132665# 0.0346f
C87 BIAS_P_4 BIAS_N_0 0.0253f
C88 a_17005_134065# m2_18279_124800# 0
C89 a_17005_132945# a_17005_131545# 0
C90 ESD_RAIL a_17764_148611# 1.23825p
C91 a_29878_132105# a_29878_132665# 0.0346f
C92 PAD_P BIAS_P_2 0.23889f
C93 BIAS_P_5 BIAS_P_6 1.46515f
C94 BIAS_N_0 BIAS_N_1 0.85489f
C95 PAD_P BIAS_P_0 1.11529f
C96 PAD_N BIAS_P_2 0.26224f
C97 BIAS_N_4 BIAS_N_5 2.15441f
C98 PAD_N BIAS_P_0 0.65412f
C99 PAD_P BIAS_N_6 0.23379f
C100 ESD_RAIL a_29878_131545# 0.56772f
C101 ESD_RAIL a_17005_132945# 0.53823f
C102 PAD_N BIAS_N_6 0.2563f
C103 BIAS_P_5 PAD_P 0.24067f
C104 BIAS_P_3 BIAS_P_4 3.16384f
C105 BIAS_P_5 PAD_N 0.36873f
C106 BIAS_P_1 BIAS_N_0 0.32139f
C107 a_17005_132945# a_17005_132385# 0.0346f
C108 a_19813_117064# a_17005_131545# 2.2693f
C109 ESD_RAIL PAD_P 24.1165f
C110 a_17005_134065# ESD_RAIL 0.57348f
C111 ATB_ESD_RAIL VSS 0.86326f
C112 PAD_P VSS 0.28034p
C113 PAD_N VSS 0.29367p
C114 VCM VSS 55.7105f
C115 ESD_RAIL VSS 1858.215664f
C116 m2_18279_124800# VSS 7.46506f $ **FLOATING
C117 a_18245_90628# VSS 0.24984p
C118 a_20789_117064# VSS 12.0947f
C119 a_19813_117064# VSS 5.60447f
C120 BIAS_P_0 VSS 4.67095f
C121 BIAS_P_3 VSS 4.33542f
C122 BIAS_P_2 VSS 4.03008f
C123 BIAS_P_1 VSS 6.04814f
C124 BIAS_P_6 VSS 4.5349f
C125 BIAS_P_5 VSS 4.04847f
C126 BIAS_P_4 VSS 6.30889f
C127 BIAS_N_2 VSS 4.52731f
C128 BIAS_N_1 VSS 4.29251f
C129 BIAS_N_0 VSS 7.62753f
C130 BIAS_N_5 VSS 4.46932f
C131 BIAS_N_4 VSS 4.23742f
C132 BIAS_N_3 VSS 6.90398f
C133 BIAS_N_6 VSS 6.72764f
C134 a_17005_131545# VSS 0.10822p
C135 a_29878_131545# VSS 0.07835f
C136 a_17005_131825# VSS 0.07377f
C137 a_29878_132105# VSS 0.07394f
C138 a_17005_132385# VSS 0.07377f
C139 a_29878_132665# VSS 0.07394f
C140 a_17005_132945# VSS 0.07377f
C141 a_29878_133225# VSS 0.07394f
C142 a_17005_133505# VSS 0.07377f
C143 a_29878_133785# VSS 0.07394f
C144 a_17005_134065# VSS 0.07377f
C145 a_29878_134345# VSS 0.07838f
C146 a_17764_148611# VSS 0.46881p
C147 a_17764_160995# VSS 1.7103p
DWELL_ARRAY VSS ESD_RAIL diode_nw2ps_06v0 area=569.4528p pj=470.72u
.ends

.lib /home/ubuntu/svalbard/scratch/transceiver-pad-pdk/ngspice/sm141064.ngspice diode_typical
.lib /home/ubuntu/svalbard/scratch/transceiver-pad-pdk/ngspice/sm141064.ngspice mimcap_typical
