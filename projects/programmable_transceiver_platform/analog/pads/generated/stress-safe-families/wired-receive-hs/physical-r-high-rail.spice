.subckt hs_protected_pad DVDD VSS VDD TERM_VCM TERM_ENABLE TERM_TRIM0 TERM_TRIM1 TERM_TRIM2 TERM_TRIM3 VBIAS RX_P RX_N PAD_P PAD_N
XPHYSICAL DVDD ESD_RAIL VSS VDD TERM_VCM TERM_ENABLE TERM_TRIM0 TERM_TRIM1 TERM_TRIM2 TERM_TRIM3 VBIAS RX_P RX_N PAD_P PAD_N pad_hspad_flat
* under-rail capacitance (mkrail.py): with rail cell {'PAD_P': 758.2251500000002, 'PAD_N': 748.1597200000001}, cell alone {'PAD_N': 542.5677499999999, 'PAD_P': 552.17191}
CRAIL_P PAD_P VSS 206.05f
CRAIL_N PAD_N VSS 205.59f
.ends hs_protected_pad
* NGSPICE file created from pad_hspad_flat.ext - technology: gf180mcuD

.subckt pad_hspad_flat DVDD ESD_RAIL VSS VDD TERM_VCM TERM_ENABLE TERM_TRIM0 TERM_TRIM1 TERM_TRIM2 TERM_TRIM3 VBIAS RX_P RX_N PAD_P PAD_N
X0 ESD_RAIL a_1852_148519# VSS VSS nfet_06v0 ad=13.936p pd=54.12u as=13.936p ps=54.12u w=53.6u l=0.7u
X1 ESD_RAIL a_1852_148519# VSS VSS nfet_06v0 ad=13.936p pd=54.12u as=13.936p ps=54.12u w=53.6u l=0.7u
X2 a_68216_149604# TERM_ENABLE TERM_VCM__N0 VSS nfet_06v0 ad=8.8p pd=40.88u as=8.8p ps=40.88u w=20u l=0.7u
X3 ESD_RAIL a_2245_90628# VSS VSS nfet_06v0 ad=22p pd=0.10088m as=13p ps=50.52u w=50u l=0.7u
X4 a_1005_133505# a_13878_133225# ESD_RAIL ppolyf_u r_width=0.8u r_length=63.855u
X5 ESD_RAIL a_1852_148519# VSS VSS nfet_06v0 ad=13.936p pd=54.12u as=23.584p ps=0.10808m w=53.6u l=0.7u
X6 ESD_RAIL a_1852_148519# VSS VSS nfet_06v0 ad=13.936p pd=54.12u as=13.936p ps=54.12u w=53.6u l=0.7u
X7 VSS a_1852_148519# ESD_RAIL VSS nfet_06v0 ad=13.936p pd=54.12u as=13.936p ps=54.12u w=53.6u l=0.7u
X8 RX_N__dev VBIAS VSS ppolyf_u_1k r_width=1u r_length=40u
X9 VSS a_2245_90628# ESD_RAIL VSS nfet_06v0 ad=13p pd=50.52u as=13p ps=50.52u w=50u l=0.7u
X10 VSS a_1852_148519# ESD_RAIL VSS nfet_06v0 ad=13.936p pd=54.12u as=13.936p ps=54.12u w=53.6u l=0.7u
X11 ESD_RAIL a_1852_148519# VSS VSS nfet_06v0 ad=13.936p pd=54.12u as=13.936p ps=54.12u w=53.6u l=0.7u
X12 VSS a_1852_148519# ESD_RAIL VSS nfet_06v0 ad=13.936p pd=54.12u as=13.936p ps=54.12u w=53.6u l=0.7u
X13 ESD_RAIL a_2245_90628# VSS VSS nfet_06v0 ad=22p pd=0.10088m as=13p ps=50.52u w=50u l=0.7u
X14 ESD_RAIL a_4789_117064# a_2245_90628# ESD_RAIL pfet_06v0 ad=1.3p pd=5.52u as=1.3p ps=5.52u w=5u l=0.7u
D0 a_76544_152994# DVDD__sN8 diode_pd2nw_06v0 pj=4u area=1p
X15 ESD_RAIL a_1852_148519# VSS VSS nfet_06v0 ad=13.936p pd=54.12u as=13.936p ps=54.12u w=53.6u l=0.7u
X16 ESD_RAIL a_1852_148519# VSS VSS nfet_06v0 ad=13.936p pd=54.12u as=13.936p ps=54.12u w=53.6u l=0.7u
X17 ESD_RAIL a_4789_117064# a_2245_90628# ESD_RAIL pfet_06v0 ad=1.3p pd=5.52u as=1.3p ps=5.52u w=5u l=0.7u
X18 VSS a_1852_148519# ESD_RAIL VSS nfet_06v0 ad=13.936p pd=54.12u as=13.936p ps=54.12u w=53.6u l=0.7u
X19 RX_P__mim PAD_P__mim cap_mim_2f0_m4m5_noshield c_width=35u c_length=35u
X20 ESD_RAIL a_2245_90628# VSS VSS nfet_06v0 ad=13p pd=50.52u as=13p ps=50.52u w=50u l=0.7u
X21 ESD_RAIL a_13878_134345# ESD_RAIL ppolyf_u r_width=0.8u r_length=63.855u
X22 ESD_RAIL a_1852_148519# VSS VSS nfet_06v0 ad=13.936p pd=54.12u as=13.936p ps=54.12u w=53.6u l=0.7u
X23 VSS a_1852_148519# ESD_RAIL VSS nfet_06v0 ad=13.936p pd=54.12u as=13.936p ps=54.12u w=53.6u l=0.7u
X24 ESD_RAIL a_1852_148519# VSS VSS nfet_06v0 ad=13.936p pd=54.12u as=13.936p ps=54.12u w=53.6u l=0.7u
X25 ESD_RAIL a_1852_148519# VSS VSS nfet_06v0 ad=13.936p pd=54.12u as=13.936p ps=54.12u w=53.6u l=0.7u
X26 PAD_P__h10 a_78592_93106_r# VSS ppolyf_u r_width=2u r_length=1u
X27 VSS a_1852_148519# ESD_RAIL VSS nfet_06v0 ad=13.936p pd=54.12u as=13.936p ps=54.12u w=53.6u l=0.7u
X28 a_73472_152994_r# PAD_N__h5 VSS ppolyf_u r_width=2u r_length=4.2u
X29 ESD_RAIL a_2245_90628# VSS VSS nfet_06v0 ad=13p pd=50.52u as=13p ps=50.52u w=50u l=0.7u
X30 ESD_RAIL a_1852_148519# VSS VSS nfet_06v0 ad=13.936p pd=54.12u as=13.936p ps=54.12u w=53.6u l=0.7u
X31 a_75520_152994# TERM_ENABLE TERM_VCM__N7 VSS nfet_06v0 ad=8.8p pd=40.88u as=8.8p ps=40.88u w=20u l=0.7u
X32 PAD_P__h2 a_70400_93106_r# VSS ppolyf_u r_width=2u r_length=4.2u
X33 VSS a_1852_148519# ESD_RAIL VSS nfet_06v0 ad=13.936p pd=54.12u as=13.936p ps=54.12u w=53.6u l=0.7u
X34 VSS a_2245_90628# ESD_RAIL VSS nfet_06v0 ad=13p pd=50.52u as=22p ps=0.10088m w=50u l=0.7u
X35 a_73472_152994# TERM_ENABLE TERM_VCM__N5 VSS nfet_06v0 ad=8.8p pd=40.88u as=8.8p ps=40.88u w=20u l=0.7u
X36 VSS a_1852_148519# ESD_RAIL VSS nfet_06v0 ad=23.584p pd=0.10808m as=13.936p ps=54.12u w=53.6u l=0.7u
X37 VSS a_2245_90628# ESD_RAIL VSS nfet_06v0 ad=13p pd=50.52u as=13p ps=50.52u w=50u l=0.7u
X38 VSS a_1852_148519# ESD_RAIL VSS nfet_06v0 ad=13.936p pd=54.12u as=13.936p ps=54.12u w=53.6u l=0.7u
X39 VSS a_1852_148519# ESD_RAIL VSS nfet_06v0 ad=13.936p pd=54.12u as=13.936p ps=54.12u w=53.6u l=0.7u
X40 VSS a_1852_148519# ESD_RAIL VSS nfet_06v0 ad=23.584p pd=0.10808m as=13.936p ps=54.12u w=53.6u l=0.7u
X41 VSS a_2245_90628# ESD_RAIL VSS nfet_06v0 ad=13p pd=50.52u as=13p ps=50.52u w=50u l=0.7u
X42 ESD_RAIL a_1852_148519# VSS VSS nfet_06v0 ad=13.936p pd=54.12u as=13.936p ps=54.12u w=53.6u l=0.7u
X43 PAD_P__h8 a_76544_93106_r# VSS ppolyf_u r_width=2u r_length=4.2u
X44 a_76544_93106# TERM_ENABLE TERM_VCM__P8 VSS nfet_06v0 ad=8.8p pd=40.88u as=8.8p ps=40.88u w=20u l=0.7u
X45 a_75520_152994_r# PAD_N__h7 VSS ppolyf_u r_width=2u r_length=4.2u
D1 a_77568_152994# DVDD__sN9 diode_pd2nw_06v0 pj=4u area=1p
X46 ESD_RAIL a_1852_148519# VSS VSS nfet_06v0 ad=13.936p pd=54.12u as=13.936p ps=54.12u w=53.6u l=0.7u
X47 ESD_RAIL a_2245_90628# VSS VSS nfet_06v0 ad=13p pd=50.52u as=13p ps=50.52u w=50u l=0.7u
X48 VSS a_1852_148519# ESD_RAIL VSS nfet_06v0 ad=13.936p pd=54.12u as=13.936p ps=54.12u w=53.6u l=0.7u
X49 VSS a_1852_148519# ESD_RAIL VSS nfet_06v0 ad=13.936p pd=54.12u as=13.936p ps=54.12u w=53.6u l=0.7u
X50 a_87808_152994_r# PAD_N__h19 VSS ppolyf_u r_width=2u r_length=1u
X51 ESD_RAIL a_1852_148519# VSS VSS nfet_06v0 ad=13.936p pd=54.12u as=13.936p ps=54.12u w=53.6u l=0.7u
X52 ESD_RAIL a_1852_148519# VSS VSS nfet_06v0 ad=13.936p pd=54.12u as=13.936p ps=54.12u w=53.6u l=0.7u
X53 a_71424_93106# TERM_ENABLE TERM_VCM__P3 VSS nfet_06v0 ad=8.8p pd=40.88u as=8.8p ps=40.88u w=20u l=0.7u
X54 ESD_RAIL a_1852_148519# VSS VSS nfet_06v0 ad=13.936p pd=54.12u as=13.936p ps=54.12u w=53.6u l=0.7u
X55 a_79616_152994_r# PAD_N__h11 VSS ppolyf_u r_width=2u r_length=1u
X56 VSS a_1852_148519# ESD_RAIL VSS nfet_06v0 ad=13.936p pd=54.12u as=13.936p ps=54.12u w=53.6u l=0.7u
X57 VSS a_1852_148519# ESD_RAIL VSS nfet_06v0 ad=13.936p pd=54.12u as=13.936p ps=54.12u w=53.6u l=0.7u
X58 VSS a_1852_148519# ESD_RAIL VSS nfet_06v0 ad=23.584p pd=0.10808m as=13.936p ps=54.12u w=53.6u l=0.7u
X59 ESD_RAIL a_1852_148519# VSS VSS nfet_06v0 ad=13.936p pd=54.12u as=13.936p ps=54.12u w=53.6u l=0.7u
X60 a_68216_96594# TERM_ENABLE TERM_VCM__P0 VSS nfet_06v0 ad=8.8p pd=40.88u as=8.8p ps=40.88u w=20u l=0.7u
X61 ESD_RAIL a_2245_90628# VSS VSS nfet_06v0 ad=13p pd=50.52u as=13p ps=50.52u w=50u l=0.7u
X62 ESD_RAIL a_1005_131545# a_3813_117064# ESD_RAIL pfet_06v0 ad=1.3p pd=5.52u as=1.3p ps=5.52u w=5u l=0.7u
D2 VSS__aN PAD_N__dn diode_nd2ps_06v0 pj=51.8u area=22.5p
D3 VSS__aP PAD_P__dn diode_nd2ps_06v0 pj=51.8u area=22.5p
X63 a_74496_152994# TERM_ENABLE TERM_VCM__N6 VSS nfet_06v0 ad=8.8p pd=40.88u as=8.8p ps=40.88u w=20u l=0.7u
D4 PAD_N__up DVDD__kN diode_pd2nw_06v0 pj=51.8u area=22.5p
X64 ESD_RAIL a_1852_148519# VSS VSS nfet_06v0 ad=13.936p pd=54.12u as=13.936p ps=54.12u w=53.6u l=0.7u
X65 ESD_RAIL a_1852_148519# VSS VSS nfet_06v0 ad=13.936p pd=54.12u as=13.936p ps=54.12u w=53.6u l=0.7u
X66 VSS a_1852_148519# ESD_RAIL VSS nfet_06v0 ad=13.936p pd=54.12u as=13.936p ps=54.12u w=53.6u l=0.7u
D5 PAD_P__up DVDD__kP diode_pd2nw_06v0 pj=51.8u area=22.5p
X67 a_72448_152994# TERM_ENABLE TERM_VCM__N4 VSS nfet_06v0 ad=8.8p pd=40.88u as=8.8p ps=40.88u w=20u l=0.7u
X68 VSS a_1852_148519# ESD_RAIL VSS nfet_06v0 ad=13.936p pd=54.12u as=13.936p ps=54.12u w=53.6u l=0.7u
X69 a_85760_93106# TERM_TRIM3 TERM_VCM__P17 VSS nfet_06v0 ad=5.28p pd=24.88u as=5.28p ps=24.88u w=12u l=0.7u
X70 ESD_RAIL a_1852_148519# VSS VSS nfet_06v0 ad=13.936p pd=54.12u as=13.936p ps=54.12u w=53.6u l=0.7u
X71 ESD_RAIL a_1852_148519# VSS VSS nfet_06v0 ad=13.936p pd=54.12u as=13.936p ps=54.12u w=53.6u l=0.7u
X72 VSS a_2245_90628# ESD_RAIL VSS nfet_06v0 ad=13p pd=50.52u as=13p ps=50.52u w=50u l=0.7u
X73 a_80640_93106# TERM_TRIM1 TERM_VCM__P12 VSS nfet_06v0 ad=5.28p pd=24.88u as=5.28p ps=24.88u w=12u l=0.7u
X74 a_80640_152994_r# PAD_N__h12 VSS ppolyf_u r_width=2u r_length=1u
X75 VSS a_1852_148519# ESD_RAIL VSS nfet_06v0 ad=13.936p pd=54.12u as=13.936p ps=54.12u w=53.6u l=0.7u
X76 VSS a_2245_90628# ESD_RAIL VSS nfet_06v0 ad=13p pd=50.52u as=13p ps=50.52u w=50u l=0.7u
X77 VSS a_2245_90628# ESD_RAIL VSS nfet_06v0 ad=13p pd=50.52u as=13p ps=50.52u w=50u l=0.7u
X78 ESD_RAIL a_1852_148519# VSS VSS nfet_06v0 ad=13.936p pd=54.12u as=13.936p ps=54.12u w=53.6u l=0.7u
X79 VSS a_1852_148519# ESD_RAIL VSS nfet_06v0 ad=13.936p pd=54.12u as=13.936p ps=54.12u w=53.6u l=0.7u
X80 ESD_RAIL a_2245_90628# VSS VSS nfet_06v0 ad=13p pd=50.52u as=13p ps=50.52u w=50u l=0.7u
D6 a_70400_152994# DVDD__sN2 diode_pd2nw_06v0 pj=4u area=1p
X81 VSS a_1852_148519# ESD_RAIL VSS nfet_06v0 ad=13.936p pd=54.12u as=13.936p ps=54.12u w=53.6u l=0.7u
X82 ESD_RAIL a_1852_148519# VSS VSS nfet_06v0 ad=13.936p pd=54.12u as=13.936p ps=54.12u w=53.6u l=0.7u
X83 ESD_RAIL a_1852_148519# VSS VSS nfet_06v0 ad=13.936p pd=54.12u as=13.936p ps=54.12u w=53.6u l=0.7u
X84 ESD_RAIL a_2245_90628# VSS VSS nfet_06v0 ad=13p pd=50.52u as=13p ps=50.52u w=50u l=0.7u
X85 ESD_RAIL a_2245_90628# VSS VSS nfet_06v0 ad=13p pd=50.52u as=13p ps=50.52u w=50u l=0.7u
X86 a_2245_90628# a_4789_117064# ESD_RAIL ESD_RAIL pfet_06v0 ad=1.3p pd=5.52u as=1.3p ps=5.52u w=5u l=0.7u
X87 ESD_RAIL a_1852_148519# VSS VSS nfet_06v0 ad=13.936p pd=54.12u as=13.936p ps=54.12u w=53.6u l=0.7u
X88 ESD_RAIL a_1852_148519# VSS VSS nfet_06v0 ad=13.936p pd=54.12u as=23.584p ps=0.10808m w=53.6u l=0.7u
X89 PAD_P__h16 a_84736_93106_r# VSS ppolyf_u r_width=2u r_length=1u
X90 PAD_P__h18 a_86784_93106_r# VSS ppolyf_u r_width=2u r_length=1u
D7 a_79616_93106# DVDD__sP11 diode_pd2nw_06v0 pj=4u area=1p
D8 a_87808_152994# DVDD__sN19 diode_pd2nw_06v0 pj=4u area=1p
X91 ESD_RAIL a_1852_148519# VSS VSS nfet_06v0 ad=13.936p pd=54.12u as=13.936p ps=54.12u w=53.6u l=0.7u
D9 VSS__aN PAD_N__dn diode_nd2ps_06v0 pj=51.8u area=22.5p
X92 a_71424_152994# TERM_ENABLE TERM_VCM__N3 VSS nfet_06v0 ad=8.8p pd=40.88u as=8.8p ps=40.88u w=20u l=0.7u
X93 VSS a_1852_148519# ESD_RAIL VSS nfet_06v0 ad=13.936p pd=54.12u as=13.936p ps=54.12u w=53.6u l=0.7u
X94 a_2245_90628# a_4789_117064# ESD_RAIL ESD_RAIL pfet_06v0 ad=1.3p pd=5.52u as=1.3p ps=5.52u w=5u l=0.7u
X95 VSS a_1852_148519# ESD_RAIL VSS nfet_06v0 ad=13.936p pd=54.12u as=13.936p ps=54.12u w=53.6u l=0.7u
D10 a_72448_93106# DVDD__sP4 diode_pd2nw_06v0 pj=4u area=1p
X96 ESD_RAIL a_2245_90628# VSS VSS nfet_06v0 ad=13p pd=50.52u as=13p ps=50.52u w=50u l=0.7u
X97 a_77568_152994_r# PAD_N__h9 VSS ppolyf_u r_width=2u r_length=4.2u
X98 ESD_RAIL a_4789_117064# a_2245_90628# ESD_RAIL pfet_06v0 ad=1.3p pd=5.52u as=1.3p ps=5.52u w=5u l=0.7u
X99 a_1005_132385# a_13878_132105# ESD_RAIL ppolyf_u r_width=0.8u r_length=63.855u
D11 a_85760_152994# DVDD__sN17 diode_pd2nw_06v0 pj=4u area=1p
X100 a_79616_152994# TERM_TRIM1 TERM_VCM__N11 VSS nfet_06v0 ad=5.28p pd=24.88u as=5.28p ps=24.88u w=12u l=0.7u
X101 ESD_RAIL a_1852_148519# VSS VSS nfet_06v0 ad=13.936p pd=54.12u as=13.936p ps=54.12u w=53.6u l=0.7u
X102 ESD_RAIL w_71178_112088# VSS ppolyf_u_1k_6p0 r_width=1u r_length=0.47474m
X103 a_69376_152994_r# PAD_N__h1 VSS ppolyf_u r_width=2u r_length=4.2u
X104 a_90880_93106# TERM_TRIM3 TERM_VCM__P22 VSS nfet_06v0 ad=5.28p pd=24.88u as=5.28p ps=24.88u w=12u l=0.7u
X105 ESD_RAIL a_1852_148519# VSS VSS nfet_06v0 ad=13.936p pd=54.12u as=13.936p ps=54.12u w=53.6u l=0.7u
D12 a_76544_93106# DVDD__sP8 diode_pd2nw_06v0 pj=4u area=1p
X106 VSS a_1852_148519# ESD_RAIL VSS nfet_06v0 ad=13.936p pd=54.12u as=13.936p ps=54.12u w=53.6u l=0.7u
X107 VSS a_2245_90628# ESD_RAIL VSS nfet_06v0 ad=13p pd=50.52u as=13p ps=50.52u w=50u l=0.7u
X108 VSS a_1852_148519# ESD_RAIL VSS nfet_06v0 ad=13.936p pd=54.12u as=13.936p ps=54.12u w=53.6u l=0.7u
X109 VSS a_1852_148519# ESD_RAIL VSS nfet_06v0 ad=13.936p pd=54.12u as=13.936p ps=54.12u w=53.6u l=0.7u
X110 ESD_RAIL a_4789_117064# a_2245_90628# ESD_RAIL pfet_06v0 ad=1.3p pd=5.52u as=1.3p ps=5.52u w=5u l=0.7u
D13 a_71424_152994# DVDD__sN3 diode_pd2nw_06v0 pj=4u area=1p
X111 ESD_RAIL a_1852_148519# VSS VSS nfet_06v0 ad=13.936p pd=54.12u as=13.936p ps=54.12u w=53.6u l=0.7u
X112 a_2245_90628# a_4789_117064# VSS VSS nfet_06v0 ad=1.3p pd=5.52u as=1.3p ps=5.52u w=5u l=0.7u
X113 a_2245_90628# a_4789_117064# ESD_RAIL ESD_RAIL pfet_06v0 ad=1.3p pd=5.52u as=1.3p ps=5.52u w=5u l=0.7u
X114 ESD_RAIL a_1005_131545# a_3813_117064# ESD_RAIL pfet_06v0 ad=1.3p pd=5.52u as=1.3p ps=5.52u w=5u l=0.7u
X115 ESD_RAIL a_1852_148519# VSS VSS nfet_06v0 ad=13.936p pd=54.12u as=13.936p ps=54.12u w=53.6u l=0.7u
X116 PAD_P__h4 a_72448_93106_r# VSS ppolyf_u r_width=2u r_length=4.2u
X117 VSS a_1852_148519# ESD_RAIL VSS nfet_06v0 ad=13.936p pd=54.12u as=13.936p ps=54.12u w=53.6u l=0.7u
D14 a_89856_93106# DVDD__sP21 diode_pd2nw_06v0 pj=4u area=1p
X118 VSS a_1852_148519# ESD_RAIL VSS nfet_06v0 ad=13.936p pd=54.12u as=13.936p ps=54.12u w=53.6u l=0.7u
X119 VSS a_2245_90628# ESD_RAIL VSS nfet_06v0 ad=13p pd=50.52u as=13p ps=50.52u w=50u l=0.7u
X120 ESD_RAIL a_1852_148519# VSS VSS nfet_06v0 ad=13.936p pd=54.12u as=23.584p ps=0.10808m w=53.6u l=0.7u
X121 ESD_RAIL a_1852_148519# VSS VSS nfet_06v0 ad=13.936p pd=54.12u as=23.584p ps=0.10808m w=53.6u l=0.7u
X122 ESD_RAIL a_1852_148519# VSS VSS nfet_06v0 ad=13.936p pd=54.12u as=13.936p ps=54.12u w=53.6u l=0.7u
D15 a_73472_93106# DVDD__sP5 diode_pd2nw_06v0 pj=4u area=1p
X123 a_78592_152994# TERM_TRIM0 TERM_VCM__N10 VSS nfet_06v0 ad=5.28p pd=24.88u as=5.28p ps=24.88u w=12u l=0.7u
X124 a_2245_90628# a_4789_117064# ESD_RAIL ESD_RAIL pfet_06v0 ad=1.3p pd=5.52u as=1.3p ps=5.52u w=5u l=0.7u
D16 a_82688_93106# DVDD__sP14 diode_pd2nw_06v0 pj=4u area=1p
X125 VSS a_1852_148519# ESD_RAIL VSS nfet_06v0 ad=23.584p pd=0.10808m as=13.936p ps=54.12u w=53.6u l=0.7u
D17 a_68216_149604# DVDD__sN0 diode_pd2nw_06v0 pj=4u area=1p
X126 VSS a_1852_148519# ESD_RAIL VSS nfet_06v0 ad=13.936p pd=54.12u as=13.936p ps=54.12u w=53.6u l=0.7u
X127 VSS a_1852_148519# ESD_RAIL VSS nfet_06v0 ad=13.936p pd=54.12u as=13.936p ps=54.12u w=53.6u l=0.7u
D18 a_86784_152994# DVDD__sN18 diode_pd2nw_06v0 pj=4u area=1p
X128 ESD_RAIL a_2245_90628# VSS VSS nfet_06v0 ad=13p pd=50.52u as=13p ps=50.52u w=50u l=0.7u
X129 a_80640_152994# TERM_TRIM1 TERM_VCM__N12 VSS nfet_06v0 ad=5.28p pd=24.88u as=5.28p ps=24.88u w=12u l=0.7u
X130 VSS a_1852_148519# ESD_RAIL VSS nfet_06v0 ad=13.936p pd=54.12u as=13.936p ps=54.12u w=53.6u l=0.7u
X131 a_1005_131545# VSS cap_mim_2f0_m4m5_noshield c_width=14u c_length=14u
X132 ESD_RAIL a_2245_90628# VSS VSS nfet_06v0 ad=13p pd=50.52u as=13p ps=50.52u w=50u l=0.7u
X133 ESD_RAIL a_1852_148519# VSS VSS nfet_06v0 ad=13.936p pd=54.12u as=13.936p ps=54.12u w=53.6u l=0.7u
D19 a_86784_93106# DVDD__sP18 diode_pd2nw_06v0 pj=4u area=1p
X134 a_86784_93106# TERM_TRIM3 TERM_VCM__P18 VSS nfet_06v0 ad=5.28p pd=24.88u as=5.28p ps=24.88u w=12u l=0.7u
D20 a_72448_152994# DVDD__sN4 diode_pd2nw_06v0 pj=4u area=1p
X135 ESD_RAIL a_1852_148519# VSS VSS nfet_06v0 ad=13.936p pd=54.12u as=13.936p ps=54.12u w=53.6u l=0.7u
X136 a_1005_131825# a_13878_132105# ESD_RAIL ppolyf_u r_width=0.8u r_length=63.855u
X137 VSS a_1852_148519# ESD_RAIL VSS nfet_06v0 ad=23.584p pd=0.10808m as=13.936p ps=54.12u w=53.6u l=0.7u
X138 a_79616_93106# TERM_TRIM1 TERM_VCM__P11 VSS nfet_06v0 ad=5.28p pd=24.88u as=5.28p ps=24.88u w=12u l=0.7u
X139 ESD_RAIL a_2245_90628# VSS VSS nfet_06v0 ad=13p pd=50.52u as=13p ps=50.52u w=50u l=0.7u
X140 PAD_P__h17 a_85760_93106_r# VSS ppolyf_u r_width=2u r_length=1u
X141 ESD_RAIL a_2245_90628# VSS VSS nfet_06v0 ad=13p pd=50.52u as=13p ps=50.52u w=50u l=0.7u
X142 a_2245_90628# a_4789_117064# ESD_RAIL ESD_RAIL pfet_06v0 ad=1.3p pd=5.52u as=1.3p ps=5.52u w=5u l=0.7u
X143 ESD_RAIL a_2245_90628# VSS VSS nfet_06v0 ad=13p pd=50.52u as=13p ps=50.52u w=50u l=0.7u
X144 VSS a_2245_90628# ESD_RAIL VSS nfet_06v0 ad=13p pd=50.52u as=13p ps=50.52u w=50u l=0.7u
X145 VSS a_1852_148519# ESD_RAIL VSS nfet_06v0 ad=13.936p pd=54.12u as=13.936p ps=54.12u w=53.6u l=0.7u
D21 a_69376_152994# DVDD__sN1 diode_pd2nw_06v0 pj=4u area=1p
X146 ESD_RAIL a_1852_148519# VSS VSS nfet_06v0 ad=13.936p pd=54.12u as=13.936p ps=54.12u w=53.6u l=0.7u
X147 ESD_RAIL a_1852_148519# VSS VSS nfet_06v0 ad=13.936p pd=54.12u as=13.936p ps=54.12u w=53.6u l=0.7u
X148 VSS a_2245_90628# ESD_RAIL VSS nfet_06v0 ad=13p pd=50.52u as=13p ps=50.52u w=50u l=0.7u
X149 PAD_P__h24 a_92928_93106_r# VSS ppolyf_u r_width=2u r_length=1u
X150 a_2245_90628# a_4789_117064# ESD_RAIL ESD_RAIL pfet_06v0 ad=1.3p pd=5.52u as=1.3p ps=5.52u w=5u l=0.7u
X151 VSS a_1852_148519# ESD_RAIL VSS nfet_06v0 ad=13.936p pd=54.12u as=13.936p ps=54.12u w=53.6u l=0.7u
X152 VSS a_4789_117064# a_2245_90628# VSS nfet_06v0 ad=2.2p pd=10.88u as=1.3p ps=5.52u w=5u l=0.7u
X153 ESD_RAIL a_4789_117064# a_2245_90628# ESD_RAIL pfet_06v0 ad=1.3p pd=5.52u as=1.3p ps=5.52u w=5u l=0.7u
X154 ESD_RAIL a_2245_90628# VSS VSS nfet_06v0 ad=22p pd=0.10088m as=13p ps=50.52u w=50u l=0.7u
X155 a_72448_93106# TERM_ENABLE TERM_VCM__P4 VSS nfet_06v0 ad=8.8p pd=40.88u as=8.8p ps=40.88u w=20u l=0.7u
X156 a_1005_132945# a_13878_133225# ESD_RAIL ppolyf_u r_width=0.8u r_length=63.855u
X157 ESD_RAIL a_1852_148519# VSS VSS nfet_06v0 ad=13.936p pd=54.12u as=13.936p ps=54.12u w=53.6u l=0.7u
X158 a_89856_152994_r# PAD_N__h21 VSS ppolyf_u r_width=2u r_length=1u
X159 ESD_RAIL a_1852_148519# VSS VSS nfet_06v0 ad=13.936p pd=54.12u as=13.936p ps=54.12u w=53.6u l=0.7u
X160 ESD_RAIL a_1852_148519# VSS VSS nfet_06v0 ad=13.936p pd=54.12u as=13.936p ps=54.12u w=53.6u l=0.7u
X161 VSS a_1852_148519# ESD_RAIL VSS nfet_06v0 ad=13.936p pd=54.12u as=13.936p ps=54.12u w=53.6u l=0.7u
X162 a_88832_152994# TERM_TRIM3 TERM_VCM__N20 VSS nfet_06v0 ad=5.28p pd=24.88u as=5.28p ps=24.88u w=12u l=0.7u
X163 ESD_RAIL a_4789_117064# a_2245_90628# ESD_RAIL pfet_06v0 ad=1.3p pd=5.52u as=1.3p ps=5.52u w=5u l=0.7u
X164 ESD_RAIL a_1852_148519# VSS VSS nfet_06v0 ad=13.936p pd=54.12u as=13.936p ps=54.12u w=53.6u l=0.7u
X165 a_2245_90628# a_4789_117064# VSS VSS nfet_06v0 ad=1.3p pd=5.52u as=1.3p ps=5.52u w=5u l=0.7u
D22 VSS__aP PAD_P__dn diode_nd2ps_06v0 pj=51.8u area=22.5p
X166 a_69376_93106# TERM_ENABLE TERM_VCM__P1 VSS nfet_06v0 ad=8.8p pd=40.88u as=8.8p ps=40.88u w=20u l=0.7u
X167 a_2245_90628# a_4789_117064# ESD_RAIL ESD_RAIL pfet_06v0 ad=1.3p pd=5.52u as=2.2p ps=10.88u w=5u l=0.7u
D23 PAD_N__up DVDD__kN diode_pd2nw_06v0 pj=51.8u area=22.5p
X168 a_3813_117064# a_1005_131545# VSS VSS nfet_06v0 ad=2.2p pd=10.88u as=2.2p ps=10.88u w=5u l=0.7u
D24 PAD_P__up DVDD__kP diode_pd2nw_06v0 pj=51.8u area=22.5p
D25 VSS__aP PAD_P__dn diode_nd2ps_06v0 pj=51.8u area=22.5p
D26 a_91904_93106# DVDD__sP23 diode_pd2nw_06v0 pj=4u area=1p
X169 VSS a_1852_148519# ESD_RAIL VSS nfet_06v0 ad=13.936p pd=54.12u as=13.936p ps=54.12u w=53.6u l=0.7u
X170 VSS a_1852_148519# ESD_RAIL VSS nfet_06v0 ad=13.936p pd=54.12u as=13.936p ps=54.12u w=53.6u l=0.7u
X171 VSS a_1852_148519# ESD_RAIL VSS nfet_06v0 ad=13.936p pd=54.12u as=13.936p ps=54.12u w=53.6u l=0.7u
X172 VSS a_1852_148519# ESD_RAIL VSS nfet_06v0 ad=13.936p pd=54.12u as=13.936p ps=54.12u w=53.6u l=0.7u
X173 a_91904_152994_r# PAD_N__h23 VSS ppolyf_u r_width=2u r_length=1u
X174 a_74496_152994_r# PAD_N__h6 VSS ppolyf_u r_width=2u r_length=4.2u
X175 ESD_RAIL a_2245_90628# VSS VSS nfet_06v0 ad=13p pd=50.52u as=13p ps=50.52u w=50u l=0.7u
X176 a_2245_90628# a_4789_117064# VSS VSS nfet_06v0 ad=1.3p pd=5.52u as=1.3p ps=5.52u w=5u l=0.7u
X177 VDD w_71178_112088# w_71178_112088# w_71178_112088# pfet_06v0 ad=1.76p pd=8.88u as=1.76p ps=8.88u w=4u l=0.55u
X178 VSS a_3813_117064# a_4789_117064# VSS nfet_06v0 ad=1.3p pd=5.52u as=1.3p ps=5.52u w=5u l=0.7u
X179 a_2245_90628# a_4789_117064# ESD_RAIL ESD_RAIL pfet_06v0 ad=1.3p pd=5.52u as=1.3p ps=5.52u w=5u l=0.7u
X180 ESD_RAIL a_1852_148519# VSS VSS nfet_06v0 ad=13.936p pd=54.12u as=13.936p ps=54.12u w=53.6u l=0.7u
X181 VSS a_1852_148519# ESD_RAIL VSS nfet_06v0 ad=13.936p pd=54.12u as=13.936p ps=54.12u w=53.6u l=0.7u
X182 a_83712_152994_r# PAD_N__h15 VSS ppolyf_u r_width=2u r_length=1u
X183 a_1005_134065# a_13878_134345# ESD_RAIL ppolyf_u r_width=0.8u r_length=63.855u
X184 ESD_RAIL a_2245_90628# VSS VSS nfet_06v0 ad=13p pd=50.52u as=13p ps=50.52u w=50u l=0.7u
X185 ESD_RAIL a_1852_148519# VSS VSS nfet_06v0 ad=13.936p pd=54.12u as=13.936p ps=54.12u w=53.6u l=0.7u
X186 PAD_P__h22 a_90880_93106_r# VSS ppolyf_u r_width=2u r_length=1u
X187 ESD_RAIL a_2245_90628# VSS VSS nfet_06v0 ad=13p pd=50.52u as=13p ps=50.52u w=50u l=0.7u
X188 VSS a_3813_117064# a_4789_117064# VSS nfet_06v0 ad=1.3p pd=5.52u as=1.3p ps=5.52u w=5u l=0.7u
X189 PAD_P__h15 a_83712_93106_r# VSS ppolyf_u r_width=2u r_length=1u
X190 VSS a_1852_148519# ESD_RAIL VSS nfet_06v0 ad=13.936p pd=54.12u as=13.936p ps=54.12u w=53.6u l=0.7u
X191 ESD_RAIL a_1852_148519# VSS VSS nfet_06v0 ad=13.936p pd=54.12u as=13.936p ps=54.12u w=53.6u l=0.7u
X192 VSS a_2245_90628# ESD_RAIL VSS nfet_06v0 ad=13p pd=50.52u as=13p ps=50.52u w=50u l=0.7u
X193 RX_P__dev VSS VSS VSS nfet_06v0 ad=1.76p pd=8.88u as=1.76p ps=8.88u w=4u l=0.7u
X194 a_87808_152994# TERM_TRIM3 TERM_VCM__N19 VSS nfet_06v0 ad=5.28p pd=24.88u as=5.28p ps=24.88u w=12u l=0.7u
X195 VSS a_1852_148519# ESD_RAIL VSS nfet_06v0 ad=13.936p pd=54.12u as=13.936p ps=54.12u w=53.6u l=0.7u
X196 ESD_RAIL a_2245_90628# VSS VSS nfet_06v0 ad=13p pd=50.52u as=13p ps=50.52u w=50u l=0.7u
D27 a_80640_152994# DVDD__sN12 diode_pd2nw_06v0 pj=4u area=1p
X197 VSS a_1852_148519# ESD_RAIL VSS nfet_06v0 ad=13.936p pd=54.12u as=13.936p ps=54.12u w=53.6u l=0.7u
X198 ESD_RAIL a_1852_148519# VSS VSS nfet_06v0 ad=13.936p pd=54.12u as=13.936p ps=54.12u w=53.6u l=0.7u
X199 a_74496_93106# TERM_ENABLE TERM_VCM__P6 VSS nfet_06v0 ad=8.8p pd=40.88u as=8.8p ps=40.88u w=20u l=0.7u
X200 VSS a_1852_148519# ESD_RAIL VSS nfet_06v0 ad=13.936p pd=54.12u as=13.936p ps=54.12u w=53.6u l=0.7u
D28 a_79616_152994# DVDD__sN11 diode_pd2nw_06v0 pj=4u area=1p
X201 ESD_RAIL a_1852_148519# VSS VSS nfet_06v0 ad=13.936p pd=54.12u as=13.936p ps=54.12u w=53.6u l=0.7u
X202 a_2245_90628# a_4789_117064# ESD_RAIL ESD_RAIL pfet_06v0 ad=1.3p pd=5.52u as=1.3p ps=5.52u w=5u l=0.7u
X203 VSS a_1852_148519# ESD_RAIL VSS nfet_06v0 ad=23.584p pd=0.10808m as=13.936p ps=54.12u w=53.6u l=0.7u
X204 PAD_P__h1 a_69376_93106_r# VSS ppolyf_u r_width=2u r_length=4.2u
X205 ESD_RAIL a_2245_90628# VSS VSS nfet_06v0 ad=13p pd=50.52u as=13p ps=50.52u w=50u l=0.7u
X206 VSS a_1852_148519# ESD_RAIL VSS nfet_06v0 ad=13.936p pd=54.12u as=13.936p ps=54.12u w=53.6u l=0.7u
X207 VSS a_1852_148519# ESD_RAIL VSS nfet_06v0 ad=13.936p pd=54.12u as=13.936p ps=54.12u w=53.6u l=0.7u
X208 VSS a_1852_148519# ESD_RAIL VSS nfet_06v0 ad=13.936p pd=54.12u as=13.936p ps=54.12u w=53.6u l=0.7u
X209 PAD_P__h13 a_81664_93106_r# VSS ppolyf_u r_width=2u r_length=1u
X210 VSS a_2245_90628# ESD_RAIL VSS nfet_06v0 ad=13p pd=50.52u as=13p ps=50.52u w=50u l=0.7u
D29 a_81664_152994# DVDD__sN13 diode_pd2nw_06v0 pj=4u area=1p
X211 a_86784_152994# TERM_TRIM3 TERM_VCM__N18 VSS nfet_06v0 ad=5.28p pd=24.88u as=5.28p ps=24.88u w=12u l=0.7u
X212 ESD_RAIL a_2245_90628# VSS VSS nfet_06v0 ad=13p pd=50.52u as=13p ps=50.52u w=50u l=0.7u
X213 VSS a_1852_148519# ESD_RAIL VSS nfet_06v0 ad=23.584p pd=0.10808m as=13.936p ps=54.12u w=53.6u l=0.7u
X214 VSS a_1852_148519# ESD_RAIL VSS nfet_06v0 ad=23.584p pd=0.10808m as=13.936p ps=54.12u w=53.6u l=0.7u
X215 PAD_P__h20 a_88832_93106_r# VSS ppolyf_u r_width=2u r_length=1u
X216 ESD_RAIL a_1852_148519# VSS VSS nfet_06v0 ad=13.936p pd=54.12u as=13.936p ps=54.12u w=53.6u l=0.7u
X217 ESD_RAIL a_1852_148519# VSS VSS nfet_06v0 ad=13.936p pd=54.12u as=13.936p ps=54.12u w=53.6u l=0.7u
X218 VSS a_1852_148519# ESD_RAIL VSS nfet_06v0 ad=13.936p pd=54.12u as=13.936p ps=54.12u w=53.6u l=0.7u
X219 VSS a_2245_90628# ESD_RAIL VSS nfet_06v0 ad=13p pd=50.52u as=13p ps=50.52u w=50u l=0.7u
X220 VSS a_1852_148519# ESD_RAIL VSS nfet_06v0 ad=13.936p pd=54.12u as=13.936p ps=54.12u w=53.6u l=0.7u
X221 RX_P__mim PAD_P__mim cap_mim_2f0_m4m5_noshield c_width=35u c_length=35u
D30 a_78592_152994# DVDD__sN10 diode_pd2nw_06v0 pj=4u area=1p
X222 ESD_RAIL a_1852_148519# VSS VSS nfet_06v0 ad=13.936p pd=54.12u as=13.936p ps=54.12u w=53.6u l=0.7u
X223 a_87808_93106# TERM_TRIM3 TERM_VCM__P19 VSS nfet_06v0 ad=5.28p pd=24.88u as=5.28p ps=24.88u w=12u l=0.7u
X224 a_70400_152994# TERM_ENABLE TERM_VCM__N2 VSS nfet_06v0 ad=8.8p pd=40.88u as=8.8p ps=40.88u w=20u l=0.7u
X225 ESD_RAIL a_1852_148519# VSS VSS nfet_06v0 ad=13.936p pd=54.12u as=13.936p ps=54.12u w=53.6u l=0.7u
X226 VSS a_1852_148519# ESD_RAIL VSS nfet_06v0 ad=13.936p pd=54.12u as=13.936p ps=54.12u w=53.6u l=0.7u
X227 ESD_RAIL a_2245_90628# VSS VSS nfet_06v0 ad=13p pd=50.52u as=13p ps=50.52u w=50u l=0.7u
X228 VSS a_1852_148519# ESD_RAIL VSS nfet_06v0 ad=13.936p pd=54.12u as=13.936p ps=54.12u w=53.6u l=0.7u
X229 RX_P__dev VDD VDD VDD pfet_06v0 ad=1.76p pd=8.88u as=1.76p ps=8.88u w=4u l=0.55u
X230 a_88832_152994_r# PAD_N__h20 VSS ppolyf_u r_width=2u r_length=1u
D31 a_82688_152994# DVDD__sN14 diode_pd2nw_06v0 pj=4u area=1p
D32 a_68216_96594# DVDD__sP0 diode_pd2nw_06v0 pj=4u area=1p
X231 ESD_RAIL a_2245_90628# VSS VSS nfet_06v0 ad=13p pd=50.52u as=13p ps=50.52u w=50u l=0.7u
X232 ESD_RAIL a_2245_90628# VSS VSS nfet_06v0 ad=13p pd=50.52u as=13p ps=50.52u w=50u l=0.7u
D33 VSS ESD_RAIL diode_nd2ps_06v0 pj=82u area=40p
X233 ESD_RAIL a_1852_148519# VSS VSS nfet_06v0 ad=13.936p pd=54.12u as=13.936p ps=54.12u w=53.6u l=0.7u
X234 ESD_RAIL a_1852_148519# VSS VSS nfet_06v0 ad=13.936p pd=54.12u as=13.936p ps=54.12u w=53.6u l=0.7u
X235 a_4789_117064# a_3813_117064# VSS VSS nfet_06v0 ad=1.3p pd=5.52u as=2.2p ps=10.88u w=5u l=0.7u
D34 a_77568_93106# DVDD__sP9 diode_pd2nw_06v0 pj=4u area=1p
D35 VSS__aN PAD_N__dn diode_nd2ps_06v0 pj=51.8u area=22.5p
X236 PAD_P__h6 a_74496_93106_r# VSS ppolyf_u r_width=2u r_length=4.2u
X237 ESD_RAIL a_2245_90628# VSS VSS nfet_06v0 ad=13p pd=50.52u as=13p ps=50.52u w=50u l=0.7u
D36 VSS ESD_RAIL diode_nd2ps_06v0 pj=82u area=40p
X238 VSS a_1852_148519# ESD_RAIL VSS nfet_06v0 ad=13.936p pd=54.12u as=13.936p ps=54.12u w=53.6u l=0.7u
X239 VSS a_2245_90628# ESD_RAIL VSS nfet_06v0 ad=13p pd=50.52u as=13p ps=50.52u w=50u l=0.7u
X240 a_91904_152994# TERM_TRIM3 TERM_VCM__N23 VSS nfet_06v0 ad=5.28p pd=24.88u as=5.28p ps=24.88u w=12u l=0.7u
X241 PAD_P__h11 a_79616_93106_r# VSS ppolyf_u r_width=2u r_length=1u
X242 a_73472_93106# TERM_ENABLE TERM_VCM__P5 VSS nfet_06v0 ad=8.8p pd=40.88u as=8.8p ps=40.88u w=20u l=0.7u
X243 ESD_RAIL a_1852_148519# cap_mim_2f0_m4m5_noshield c_width=90u c_length=90u
D37 a_74496_93106# DVDD__sP6 diode_pd2nw_06v0 pj=4u area=1p
X244 ESD_RAIL a_1852_148519# VSS VSS nfet_06v0 ad=13.936p pd=54.12u as=13.936p ps=54.12u w=53.6u l=0.7u
X245 ESD_RAIL a_1852_148519# VSS VSS nfet_06v0 ad=13.936p pd=54.12u as=13.936p ps=54.12u w=53.6u l=0.7u
X246 a_1005_131825# a_13878_131545# ESD_RAIL ppolyf_u r_width=0.8u r_length=63.855u
D38 PAD_N__up DVDD__kN diode_pd2nw_06v0 pj=51.8u area=22.5p
X247 VSS a_1852_148519# ESD_RAIL VSS nfet_06v0 ad=13.936p pd=54.12u as=13.936p ps=54.12u w=53.6u l=0.7u
X248 ESD_RAIL VSS cap_mim_2f0_m4m5_noshield c_width=31.6u c_length=31.6u
X249 a_70400_152994_r# PAD_N__h2 VSS ppolyf_u r_width=2u r_length=4.2u
D39 PAD_P__up DVDD__kP diode_pd2nw_06v0 pj=51.8u area=22.5p
X250 ESD_RAIL a_1852_148519# VSS VSS nfet_06v0 ad=13.936p pd=54.12u as=13.936p ps=54.12u w=53.6u l=0.7u
X251 a_92928_93106# TERM_TRIM3 TERM_VCM__P24 VSS nfet_06v0 ad=5.28p pd=24.88u as=5.28p ps=24.88u w=12u l=0.7u
X252 VSS a_2245_90628# ESD_RAIL VSS nfet_06v0 ad=13p pd=50.52u as=22p ps=0.10088m w=50u l=0.7u
D40 a_91904_152994# DVDD__sN23 diode_pd2nw_06v0 pj=4u area=1p
D41 a_78592_93106# DVDD__sP10 diode_pd2nw_06v0 pj=4u area=1p
X253 a_81664_152994_r# PAD_N__h13 VSS ppolyf_u r_width=2u r_length=1u
X254 VSS a_2245_90628# ESD_RAIL VSS nfet_06v0 ad=13p pd=50.52u as=22p ps=0.10088m w=50u l=0.7u
X255 ESD_RAIL a_4789_117064# a_2245_90628# ESD_RAIL pfet_06v0 ad=1.3p pd=5.52u as=1.3p ps=5.52u w=5u l=0.7u
X256 a_92928_152994# TERM_TRIM3 TERM_VCM__N24 VSS nfet_06v0 ad=5.28p pd=24.88u as=5.28p ps=24.88u w=12u l=0.7u
X257 VSS a_1852_148519# ESD_RAIL VSS nfet_06v0 ad=13.936p pd=54.12u as=13.936p ps=54.12u w=53.6u l=0.7u
X258 ESD_RAIL a_1852_148519# VSS VSS nfet_06v0 ad=13.936p pd=54.12u as=13.936p ps=54.12u w=53.6u l=0.7u
X259 VBIAS RX_P__dev VSS ppolyf_u_1k r_width=1u r_length=40u
X260 ESD_RAIL a_1852_148519# VSS VSS nfet_06v0 ad=13.936p pd=54.12u as=13.936p ps=54.12u w=53.6u l=0.7u
X261 VSS a_1852_148519# ESD_RAIL VSS nfet_06v0 ad=13.936p pd=54.12u as=13.936p ps=54.12u w=53.6u l=0.7u
X262 VSS a_2245_90628# ESD_RAIL VSS nfet_06v0 ad=13p pd=50.52u as=13p ps=50.52u w=50u l=0.7u
X263 ESD_RAIL a_4789_117064# a_2245_90628# ESD_RAIL pfet_06v0 ad=1.3p pd=5.52u as=1.3p ps=5.52u w=5u l=0.7u
D42 a_88832_152994# DVDD__sN20 diode_pd2nw_06v0 pj=4u area=1p
X264 ESD_RAIL a_2245_90628# VSS VSS nfet_06v0 ad=13p pd=50.52u as=13p ps=50.52u w=50u l=0.7u
X265 a_1005_132945# a_13878_132665# ESD_RAIL ppolyf_u r_width=0.8u r_length=63.855u
X266 ESD_RAIL a_1852_148519# VSS VSS nfet_06v0 ad=13.936p pd=54.12u as=13.936p ps=54.12u w=53.6u l=0.7u
X267 ESD_RAIL a_2245_90628# VSS VSS nfet_06v0 ad=13p pd=50.52u as=13p ps=50.52u w=50u l=0.7u
X268 ESD_RAIL a_1852_148519# VSS VSS nfet_06v0 ad=13.936p pd=54.12u as=13.936p ps=54.12u w=53.6u l=0.7u
X269 VSS a_1852_148519# ESD_RAIL VSS nfet_06v0 ad=13.936p pd=54.12u as=13.936p ps=54.12u w=53.6u l=0.7u
X270 ESD_RAIL a_1852_148519# VSS VSS nfet_06v0 ad=13.936p pd=54.12u as=13.936p ps=54.12u w=53.6u l=0.7u
X271 ESD_RAIL a_1852_148519# VSS VSS nfet_06v0 ad=13.936p pd=54.12u as=13.936p ps=54.12u w=53.6u l=0.7u
X272 VSS a_1852_148519# ESD_RAIL VSS nfet_06v0 ad=23.584p pd=0.10808m as=13.936p ps=54.12u w=53.6u l=0.7u
X273 ESD_RAIL a_1852_148519# VSS VSS nfet_06v0 ad=13.936p pd=54.12u as=13.936p ps=54.12u w=53.6u l=0.7u
X274 VSS a_2245_90628# ESD_RAIL VSS nfet_06v0 ad=13p pd=50.52u as=13p ps=50.52u w=50u l=0.7u
D43 a_92928_152994# DVDD__sN24 diode_pd2nw_06v0 pj=4u area=1p
X275 VSS a_1852_148519# ESD_RAIL VSS nfet_06v0 ad=13.936p pd=54.12u as=13.936p ps=54.12u w=53.6u l=0.7u
X276 VSS a_1852_148519# ESD_RAIL VSS nfet_06v0 ad=13.936p pd=54.12u as=13.936p ps=54.12u w=53.6u l=0.7u
D44 a_70400_93106# DVDD__sP2 diode_pd2nw_06v0 pj=4u area=1p
D45 PAD_N__up DVDD__kN diode_pd2nw_06v0 pj=51.8u area=22.5p
X277 VSS a_1852_148519# ESD_RAIL VSS nfet_06v0 ad=13.936p pd=54.12u as=13.936p ps=54.12u w=53.6u l=0.7u
X278 VSS a_1852_148519# ESD_RAIL VSS nfet_06v0 ad=13.936p pd=54.12u as=13.936p ps=54.12u w=53.6u l=0.7u
X279 VSS a_1852_148519# ESD_RAIL VSS nfet_06v0 ad=13.936p pd=54.12u as=13.936p ps=54.12u w=53.6u l=0.7u
X280 ESD_RAIL a_1852_148519# VSS VSS nfet_06v0 ad=13.936p pd=54.12u as=13.936p ps=54.12u w=53.6u l=0.7u
X281 a_3813_117064# a_1005_131545# ESD_RAIL ESD_RAIL pfet_06v0 ad=1.3p pd=5.52u as=1.3p ps=5.52u w=5u l=0.7u
D46 a_90880_152994# DVDD__sN22 diode_pd2nw_06v0 pj=4u area=1p
X282 a_75520_93106# TERM_ENABLE TERM_VCM__P7 VSS nfet_06v0 ad=8.8p pd=40.88u as=8.8p ps=40.88u w=20u l=0.7u
X283 a_81664_93106# TERM_TRIM2 TERM_VCM__P13 VSS nfet_06v0 ad=5.28p pd=24.88u as=5.28p ps=24.88u w=12u l=0.7u
X284 VSS a_1852_148519# ESD_RAIL VSS nfet_06v0 ad=23.584p pd=0.10808m as=13.936p ps=54.12u w=53.6u l=0.7u
X285 VSS ESD_RAIL VSS ppolyf_u_1k_6p0 r_width=1u r_length=9.98874m
X286 ESD_RAIL a_1852_148519# VSS VSS nfet_06v0 ad=13.936p pd=54.12u as=13.936p ps=54.12u w=53.6u l=0.7u
X287 ESD_RAIL a_1852_148519# VSS VSS nfet_06v0 ad=13.936p pd=54.12u as=13.936p ps=54.12u w=53.6u l=0.7u
D47 a_83712_93106# DVDD__sP15 diode_pd2nw_06v0 pj=4u area=1p
D48 a_89856_152994# DVDD__sN21 diode_pd2nw_06v0 pj=4u area=1p
X288 ESD_RAIL a_1852_148519# VSS VSS nfet_06v0 ad=13.936p pd=54.12u as=23.584p ps=0.10808m w=53.6u l=0.7u
X289 a_4789_117064# a_3813_117064# ESD_RAIL ESD_RAIL pfet_06v0 ad=2.2p pd=10.88u as=1.3p ps=5.52u w=5u l=0.7u
X290 ESD_RAIL a_1852_148519# VSS VSS nfet_06v0 ad=13.936p pd=54.12u as=23.584p ps=0.10808m w=53.6u l=0.7u
D49 a_92928_93106# DVDD__sP24 diode_pd2nw_06v0 pj=4u area=1p
X291 ESD_RAIL a_2245_90628# VSS VSS nfet_06v0 ad=13p pd=50.52u as=13p ps=50.52u w=50u l=0.7u
X292 VSS a_1852_148519# ESD_RAIL VSS nfet_06v0 ad=13.936p pd=54.12u as=13.936p ps=54.12u w=53.6u l=0.7u
X293 a_84736_152994_r# PAD_N__h16 VSS ppolyf_u r_width=2u r_length=1u
X294 ESD_RAIL a_1852_148519# VSS VSS nfet_06v0 ad=13.936p pd=54.12u as=13.936p ps=54.12u w=53.6u l=0.7u
X295 ESD_RAIL a_1852_148519# VSS VSS nfet_06v0 ad=13.936p pd=54.12u as=13.936p ps=54.12u w=53.6u l=0.7u
X296 ESD_RAIL a_2245_90628# VSS VSS nfet_06v0 ad=13p pd=50.52u as=13p ps=50.52u w=50u l=0.7u
X297 VSS a_1852_148519# ESD_RAIL VSS nfet_06v0 ad=13.936p pd=54.12u as=13.936p ps=54.12u w=53.6u l=0.7u
D50 a_80640_93106# DVDD__sP12 diode_pd2nw_06v0 pj=4u area=1p
X298 a_72448_152994_r# PAD_N__h4 VSS ppolyf_u r_width=2u r_length=4.2u
D51 a_73472_152994# DVDD__sN5 diode_pd2nw_06v0 pj=4u area=1p
X299 RX_N__mim PAD_N__mim cap_mim_2f0_m4m5_noshield c_width=35u c_length=35u
X300 a_2245_90628# a_4789_117064# ESD_RAIL ESD_RAIL pfet_06v0 ad=1.3p pd=5.52u as=1.3p ps=5.52u w=5u l=0.7u
X301 VSS a_1852_148519# ESD_RAIL VSS nfet_06v0 ad=13.936p pd=54.12u as=13.936p ps=54.12u w=53.6u l=0.7u
X302 VSS a_2245_90628# ESD_RAIL VSS nfet_06v0 ad=13p pd=50.52u as=13p ps=50.52u w=50u l=0.7u
X303 ESD_RAIL a_2245_90628# VSS VSS nfet_06v0 ad=13p pd=50.52u as=13p ps=50.52u w=50u l=0.7u
X304 a_76544_152994# TERM_ENABLE TERM_VCM__N8 VSS nfet_06v0 ad=8.8p pd=40.88u as=8.8p ps=40.88u w=20u l=0.7u
X305 VSS a_1852_148519# ESD_RAIL VSS nfet_06v0 ad=13.936p pd=54.12u as=13.936p ps=54.12u w=53.6u l=0.7u
X306 a_1005_134065# a_13878_133785# ESD_RAIL ppolyf_u r_width=0.8u r_length=63.855u
X307 a_91904_93106# TERM_TRIM3 TERM_VCM__P23 VSS nfet_06v0 ad=5.28p pd=24.88u as=5.28p ps=24.88u w=12u l=0.7u
X308 ESD_RAIL a_1852_148519# VSS VSS nfet_06v0 ad=13.936p pd=54.12u as=13.936p ps=54.12u w=53.6u l=0.7u
X309 ESD_RAIL a_1852_148519# VSS VSS nfet_06v0 ad=13.936p pd=54.12u as=13.936p ps=54.12u w=53.6u l=0.7u
X310 ESD_RAIL a_1852_148519# VSS VSS nfet_06v0 ad=13.936p pd=54.12u as=13.936p ps=54.12u w=53.6u l=0.7u
X311 VSS a_2245_90628# ESD_RAIL VSS nfet_06v0 ad=13p pd=50.52u as=13p ps=50.52u w=50u l=0.7u
X312 VSS a_2245_90628# ESD_RAIL VSS nfet_06v0 ad=13p pd=50.52u as=13p ps=50.52u w=50u l=0.7u
X313 ESD_RAIL a_4789_117064# a_2245_90628# ESD_RAIL pfet_06v0 ad=1.3p pd=5.52u as=1.3p ps=5.52u w=5u l=0.7u
X314 ESD_RAIL a_1852_148519# VSS VSS nfet_06v0 ad=13.936p pd=54.12u as=13.936p ps=54.12u w=53.6u l=0.7u
X315 ESD_RAIL a_1852_148519# VSS VSS nfet_06v0 ad=13.936p pd=54.12u as=13.936p ps=54.12u w=53.6u l=0.7u
X316 a_88832_93106# TERM_TRIM3 TERM_VCM__P20 VSS nfet_06v0 ad=5.28p pd=24.88u as=5.28p ps=24.88u w=12u l=0.7u
X317 ESD_RAIL a_1852_148519# cap_mim_2f0_m4m5_noshield c_width=90u c_length=90u
X318 VSS a_2245_90628# ESD_RAIL VSS nfet_06v0 ad=13p pd=50.52u as=13p ps=50.52u w=50u l=0.7u
D52 VSS ESD_RAIL diode_nd2ps_06v0 pj=82u area=40p
X319 ESD_RAIL a_3813_117064# a_4789_117064# ESD_RAIL pfet_06v0 ad=1.3p pd=5.52u as=1.3p ps=5.52u w=5u l=0.7u
X320 VSS a_1852_148519# ESD_RAIL VSS nfet_06v0 ad=13.936p pd=54.12u as=13.936p ps=54.12u w=53.6u l=0.7u
X321 VSS a_1852_148519# ESD_RAIL VSS nfet_06v0 ad=13.936p pd=54.12u as=13.936p ps=54.12u w=53.6u l=0.7u
X322 VSS a_1852_148519# ESD_RAIL VSS nfet_06v0 ad=13.936p pd=54.12u as=13.936p ps=54.12u w=53.6u l=0.7u
X323 PAD_P__h5 a_73472_93106_r# VSS ppolyf_u r_width=2u r_length=4.2u
X324 ESD_RAIL a_1852_148519# VSS VSS nfet_06v0 ad=13.936p pd=54.12u as=13.936p ps=54.12u w=53.6u l=0.7u
X325 a_78592_152994_r# PAD_N__h10 VSS ppolyf_u r_width=2u r_length=1u
D53 a_90880_93106# DVDD__sP22 diode_pd2nw_06v0 pj=4u area=1p
X326 a_2245_90628# a_4789_117064# ESD_RAIL ESD_RAIL pfet_06v0 ad=1.3p pd=5.52u as=1.3p ps=5.52u w=5u l=0.7u
D54 a_74496_152994# DVDD__sN6 diode_pd2nw_06v0 pj=4u area=1p
X327 ESD_RAIL a_1852_148519# VSS VSS nfet_06v0 ad=13.936p pd=54.12u as=13.936p ps=54.12u w=53.6u l=0.7u
X328 a_83712_93106# TERM_TRIM2 TERM_VCM__P15 VSS nfet_06v0 ad=5.28p pd=24.88u as=5.28p ps=24.88u w=12u l=0.7u
X329 VSS a_2245_90628# ESD_RAIL VSS nfet_06v0 ad=13p pd=50.52u as=13p ps=50.52u w=50u l=0.7u
D55 VSS__aN PAD_N__dn diode_nd2ps_06v0 pj=51.8u area=22.5p
X330 VSS a_1852_148519# ESD_RAIL VSS nfet_06v0 ad=13.936p pd=54.12u as=13.936p ps=54.12u w=53.6u l=0.7u
X331 VSS a_1852_148519# ESD_RAIL VSS nfet_06v0 ad=13.936p pd=54.12u as=13.936p ps=54.12u w=53.6u l=0.7u
D56 VSS__aP PAD_P__dn diode_nd2ps_06v0 pj=51.8u area=22.5p
X332 VSS a_1852_148519# ESD_RAIL VSS nfet_06v0 ad=13.936p pd=54.12u as=13.936p ps=54.12u w=53.6u l=0.7u
X333 a_77568_152994# TERM_ENABLE TERM_VCM__N9 VSS nfet_06v0 ad=8.8p pd=40.88u as=8.8p ps=40.88u w=20u l=0.7u
X334 VSS a_1852_148519# ESD_RAIL VSS nfet_06v0 ad=13.936p pd=54.12u as=13.936p ps=54.12u w=53.6u l=0.7u
X335 a_3813_117064# a_1005_131545# ESD_RAIL ESD_RAIL pfet_06v0 ad=1.3p pd=5.52u as=2.2p ps=10.88u w=5u l=0.7u
X336 ESD_RAIL a_1852_148519# VSS VSS nfet_06v0 ad=13.936p pd=54.12u as=13.936p ps=54.12u w=53.6u l=0.7u
X337 ESD_RAIL a_1852_148519# VSS VSS nfet_06v0 ad=13.936p pd=54.12u as=23.584p ps=0.10808m w=53.6u l=0.7u
X338 ESD_RAIL a_2245_90628# VSS VSS nfet_06v0 ad=22p pd=0.10088m as=13p ps=50.52u w=50u l=0.7u
X339 ESD_RAIL a_1852_148519# VSS VSS nfet_06v0 ad=13.936p pd=54.12u as=13.936p ps=54.12u w=53.6u l=0.7u
X340 PAD_P__h7 a_75520_93106_r# VSS ppolyf_u r_width=2u r_length=4.2u
X341 ESD_RAIL a_2245_90628# VSS VSS nfet_06v0 ad=13p pd=50.52u as=13p ps=50.52u w=50u l=0.7u
X342 VSS a_1852_148519# ESD_RAIL VSS nfet_06v0 ad=13.936p pd=54.12u as=13.936p ps=54.12u w=53.6u l=0.7u
X343 ESD_RAIL a_2245_90628# VSS VSS nfet_06v0 ad=13p pd=50.52u as=13p ps=50.52u w=50u l=0.7u
X344 a_85760_152994# TERM_TRIM3 TERM_VCM__N17 VSS nfet_06v0 ad=5.28p pd=24.88u as=5.28p ps=24.88u w=12u l=0.7u
X345 VSS a_1852_148519# ESD_RAIL VSS nfet_06v0 ad=23.584p pd=0.10808m as=13.936p ps=54.12u w=53.6u l=0.7u
X346 a_4789_117064# a_3813_117064# ESD_RAIL ESD_RAIL pfet_06v0 ad=1.3p pd=5.52u as=1.3p ps=5.52u w=5u l=0.7u
X347 ESD_RAIL a_1852_148519# VSS VSS nfet_06v0 ad=13.936p pd=54.12u as=13.936p ps=54.12u w=53.6u l=0.7u
X348 a_92928_152994_r# PAD_N__h24 VSS ppolyf_u r_width=2u r_length=1u
D57 PAD_P__up DVDD__kP diode_pd2nw_06v0 pj=51.8u area=22.5p
X349 VSS a_1852_148519# ESD_RAIL VSS nfet_06v0 ad=13.936p pd=54.12u as=13.936p ps=54.12u w=53.6u l=0.7u
X350 VSS a_1852_148519# ESD_RAIL VSS nfet_06v0 ad=13.936p pd=54.12u as=13.936p ps=54.12u w=53.6u l=0.7u
X351 a_78592_93106# TERM_TRIM0 TERM_VCM__P10 VSS nfet_06v0 ad=5.28p pd=24.88u as=5.28p ps=24.88u w=12u l=0.7u
X352 ESD_RAIL a_1852_148519# VSS VSS nfet_06v0 ad=13.936p pd=54.12u as=13.936p ps=54.12u w=53.6u l=0.7u
X353 ESD_RAIL a_1852_148519# VSS VSS nfet_06v0 ad=13.936p pd=54.12u as=13.936p ps=54.12u w=53.6u l=0.7u
D58 PAD_P__up DVDD__kP diode_pd2nw_06v0 pj=51.8u area=22.5p
X354 ESD_RAIL a_1852_148519# VSS VSS nfet_06v0 ad=13.936p pd=54.12u as=13.936p ps=54.12u w=53.6u l=0.7u
X355 ESD_RAIL a_1852_148519# VSS VSS nfet_06v0 ad=13.936p pd=54.12u as=13.936p ps=54.12u w=53.6u l=0.7u
D59 a_83712_152994# DVDD__sN15 diode_pd2nw_06v0 pj=4u area=1p
X356 VSS a_2245_90628# ESD_RAIL VSS nfet_06v0 ad=13p pd=50.52u as=22p ps=0.10088m w=50u l=0.7u
X357 VSS a_2245_90628# ESD_RAIL VSS nfet_06v0 ad=13p pd=50.52u as=13p ps=50.52u w=50u l=0.7u
X358 ESD_RAIL a_1852_148519# VSS VSS nfet_06v0 ad=13.936p pd=54.12u as=13.936p ps=54.12u w=53.6u l=0.7u
X359 VSS a_1852_148519# ESD_RAIL VSS nfet_06v0 ad=13.936p pd=54.12u as=13.936p ps=54.12u w=53.6u l=0.7u
X360 VSS a_2245_90628# ESD_RAIL VSS nfet_06v0 ad=13p pd=50.52u as=13p ps=50.52u w=50u l=0.7u
X361 VSS a_2245_90628# ESD_RAIL VSS nfet_06v0 ad=13p pd=50.52u as=13p ps=50.52u w=50u l=0.7u
X362 a_1852_148519# VSS VSS ppolyf_u_1k_6p0 r_width=1u r_length=6u
X363 ESD_RAIL a_1852_148519# VSS VSS nfet_06v0 ad=13.936p pd=54.12u as=13.936p ps=54.12u w=53.6u l=0.7u
X364 VSS a_1852_148519# ESD_RAIL VSS nfet_06v0 ad=13.936p pd=54.12u as=13.936p ps=54.12u w=53.6u l=0.7u
X365 VSS a_1852_148519# ESD_RAIL VSS nfet_06v0 ad=13.936p pd=54.12u as=13.936p ps=54.12u w=53.6u l=0.7u
X366 a_84736_152994# TERM_TRIM2 TERM_VCM__N16 VSS nfet_06v0 ad=5.28p pd=24.88u as=5.28p ps=24.88u w=12u l=0.7u
X367 VSS a_1852_148519# ESD_RAIL VSS nfet_06v0 ad=23.584p pd=0.10808m as=13.936p ps=54.12u w=53.6u l=0.7u
X368 VDD w_71178_112088# w_71178_112088# w_71178_112088# pfet_06v0 ad=1.76p pd=8.88u as=1.76p ps=8.88u w=4u l=0.55u
X369 VSS a_1852_148519# ESD_RAIL VSS nfet_06v0 ad=13.936p pd=54.12u as=13.936p ps=54.12u w=53.6u l=0.7u
D60 a_69376_93106# DVDD__sP1 diode_pd2nw_06v0 pj=4u area=1p
X370 VSS a_2245_90628# ESD_RAIL VSS nfet_06v0 ad=13p pd=50.52u as=13p ps=50.52u w=50u l=0.7u
X371 a_82688_152994# TERM_TRIM2 TERM_VCM__N14 VSS nfet_06v0 ad=5.28p pd=24.88u as=5.28p ps=24.88u w=12u l=0.7u
X372 ESD_RAIL a_1852_148519# VSS VSS nfet_06v0 ad=13.936p pd=54.12u as=23.584p ps=0.10808m w=53.6u l=0.7u
X373 a_86784_152994_r# PAD_N__h18 VSS ppolyf_u r_width=2u r_length=1u
X374 VSS a_1852_148519# ESD_RAIL VSS nfet_06v0 ad=13.936p pd=54.12u as=13.936p ps=54.12u w=53.6u l=0.7u
X375 ESD_RAIL a_2245_90628# VSS VSS nfet_06v0 ad=13p pd=50.52u as=13p ps=50.52u w=50u l=0.7u
X376 ESD_RAIL a_2245_90628# VSS VSS nfet_06v0 ad=13p pd=50.52u as=13p ps=50.52u w=50u l=0.7u
X377 a_85760_152994_r# PAD_N__h17 VSS ppolyf_u r_width=2u r_length=1u
X378 a_68216_149604_r# PAD_N__h0 VSS ppolyf_u r_width=2u r_length=4.2u
X379 PAD_P__h21 a_89856_93106_r# VSS ppolyf_u r_width=2u r_length=1u
X380 ESD_RAIL a_1852_148519# VSS VSS nfet_06v0 ad=13.936p pd=54.12u as=13.936p ps=54.12u w=53.6u l=0.7u
X381 VSS a_3813_117064# a_4789_117064# VSS nfet_06v0 ad=1.3p pd=5.52u as=1.3p ps=5.52u w=5u l=0.7u
D61 a_84736_152994# DVDD__sN16 diode_pd2nw_06v0 pj=4u area=1p
X382 ESD_RAIL a_1852_148519# VSS VSS nfet_06v0 ad=13.936p pd=54.12u as=13.936p ps=54.12u w=53.6u l=0.7u
X383 VSS a_1852_148519# ESD_RAIL VSS nfet_06v0 ad=13.936p pd=54.12u as=13.936p ps=54.12u w=53.6u l=0.7u
X384 RX_N__dev VSS VSS VSS nfet_06v0 ad=1.76p pd=8.88u as=1.76p ps=8.88u w=4u l=0.7u
X385 VSS a_2245_90628# ESD_RAIL VSS nfet_06v0 ad=13p pd=50.52u as=13p ps=50.52u w=50u l=0.7u
X386 a_71424_152994_r# PAD_N__h3 VSS ppolyf_u r_width=2u r_length=4.2u
X387 ESD_RAIL a_1852_148519# VSS VSS nfet_06v0 ad=13.936p pd=54.12u as=23.584p ps=0.10808m w=53.6u l=0.7u
X388 ESD_RAIL a_1852_148519# VSS VSS nfet_06v0 ad=13.936p pd=54.12u as=13.936p ps=54.12u w=53.6u l=0.7u
X389 PAD_P__h23 a_91904_93106_r# VSS ppolyf_u r_width=2u r_length=1u
X390 a_82688_93106# TERM_TRIM2 TERM_VCM__P14 VSS nfet_06v0 ad=5.28p pd=24.88u as=5.28p ps=24.88u w=12u l=0.7u
X391 VSS a_4789_117064# a_2245_90628# VSS nfet_06v0 ad=1.3p pd=5.52u as=1.3p ps=5.52u w=5u l=0.7u
X392 VSS a_1852_148519# ESD_RAIL VSS nfet_06v0 ad=13.936p pd=54.12u as=13.936p ps=54.12u w=53.6u l=0.7u
X393 VSS a_1852_148519# ESD_RAIL VSS nfet_06v0 ad=13.936p pd=54.12u as=13.936p ps=54.12u w=53.6u l=0.7u
X394 VSS a_1852_148519# ESD_RAIL VSS nfet_06v0 ad=13.936p pd=54.12u as=13.936p ps=54.12u w=53.6u l=0.7u
X395 VSS a_4789_117064# a_2245_90628# VSS nfet_06v0 ad=1.3p pd=5.52u as=1.3p ps=5.52u w=5u l=0.7u
X396 ESD_RAIL a_4789_117064# a_2245_90628# ESD_RAIL pfet_06v0 ad=1.3p pd=5.52u as=1.3p ps=5.52u w=5u l=0.7u
X397 ESD_RAIL a_1852_148519# VSS VSS nfet_06v0 ad=13.936p pd=54.12u as=13.936p ps=54.12u w=53.6u l=0.7u
X398 VSS a_1852_148519# ESD_RAIL VSS nfet_06v0 ad=23.584p pd=0.10808m as=13.936p ps=54.12u w=53.6u l=0.7u
X399 a_1005_131545# a_13878_131545# ESD_RAIL ppolyf_u r_width=0.8u r_length=63.855u
X400 a_83712_152994# TERM_TRIM2 TERM_VCM__N15 VSS nfet_06v0 ad=5.28p pd=24.88u as=5.28p ps=24.88u w=12u l=0.7u
X401 VSS a_2245_90628# ESD_RAIL VSS nfet_06v0 ad=13p pd=50.52u as=13p ps=50.52u w=50u l=0.7u
X402 VSS a_2245_90628# ESD_RAIL VSS nfet_06v0 ad=13p pd=50.52u as=13p ps=50.52u w=50u l=0.7u
X403 ESD_RAIL a_1852_148519# VSS VSS nfet_06v0 ad=13.936p pd=54.12u as=13.936p ps=54.12u w=53.6u l=0.7u
X404 a_81664_152994# TERM_TRIM2 TERM_VCM__N13 VSS nfet_06v0 ad=5.28p pd=24.88u as=5.28p ps=24.88u w=12u l=0.7u
X405 VSS a_1852_148519# ESD_RAIL VSS nfet_06v0 ad=13.936p pd=54.12u as=13.936p ps=54.12u w=53.6u l=0.7u
X406 VSS a_1852_148519# ESD_RAIL VSS nfet_06v0 ad=13.936p pd=54.12u as=13.936p ps=54.12u w=53.6u l=0.7u
X407 ESD_RAIL a_1852_148519# VSS VSS nfet_06v0 ad=13.936p pd=54.12u as=23.584p ps=0.10808m w=53.6u l=0.7u
X408 ESD_RAIL a_1852_148519# VSS VSS nfet_06v0 ad=13.936p pd=54.12u as=23.584p ps=0.10808m w=53.6u l=0.7u
X409 ESD_RAIL a_1852_148519# VSS VSS nfet_06v0 ad=13.936p pd=54.12u as=13.936p ps=54.12u w=53.6u l=0.7u
X410 ESD_RAIL a_2245_90628# VSS VSS nfet_06v0 ad=13p pd=50.52u as=13p ps=50.52u w=50u l=0.7u
X411 a_4789_117064# a_3813_117064# VSS VSS nfet_06v0 ad=1.3p pd=5.52u as=1.3p ps=5.52u w=5u l=0.7u
X412 VSS a_1852_148519# ESD_RAIL VSS nfet_06v0 ad=13.936p pd=54.12u as=13.936p ps=54.12u w=53.6u l=0.7u
X413 VSS a_1852_148519# ESD_RAIL VSS nfet_06v0 ad=13.936p pd=54.12u as=13.936p ps=54.12u w=53.6u l=0.7u
X414 PAD_P__h3 a_71424_93106_r# VSS ppolyf_u r_width=2u r_length=4.2u
X415 a_2245_90628# a_4789_117064# ESD_RAIL ESD_RAIL pfet_06v0 ad=1.3p pd=5.52u as=1.3p ps=5.52u w=5u l=0.7u
X416 VSS a_1852_148519# ESD_RAIL VSS nfet_06v0 ad=13.936p pd=54.12u as=13.936p ps=54.12u w=53.6u l=0.7u
X417 ESD_RAIL a_1852_148519# VSS VSS nfet_06v0 ad=13.936p pd=54.12u as=13.936p ps=54.12u w=53.6u l=0.7u
X418 ESD_RAIL a_1852_148519# VSS VSS nfet_06v0 ad=13.936p pd=54.12u as=13.936p ps=54.12u w=53.6u l=0.7u
X419 VSS a_1852_148519# ESD_RAIL VSS nfet_06v0 ad=13.936p pd=54.12u as=13.936p ps=54.12u w=53.6u l=0.7u
X420 PAD_P__h9 a_77568_93106_r# VSS ppolyf_u r_width=2u r_length=4.2u
X421 a_1005_132385# a_13878_132665# ESD_RAIL ppolyf_u r_width=0.8u r_length=63.855u
X422 ESD_RAIL a_1852_148519# VSS VSS nfet_06v0 ad=13.936p pd=54.12u as=23.584p ps=0.10808m w=53.6u l=0.7u
X423 ESD_RAIL a_2245_90628# VSS VSS nfet_06v0 ad=13p pd=50.52u as=13p ps=50.52u w=50u l=0.7u
X424 ESD_RAIL a_1852_148519# VSS VSS nfet_06v0 ad=13.936p pd=54.12u as=13.936p ps=54.12u w=53.6u l=0.7u
D62 a_87808_93106# DVDD__sP19 diode_pd2nw_06v0 pj=4u area=1p
X425 PAD_P__h14 a_82688_93106_r# VSS ppolyf_u r_width=2u r_length=1u
D63 a_71424_93106# DVDD__sP3 diode_pd2nw_06v0 pj=4u area=1p
X426 VSS a_1852_148519# ESD_RAIL VSS nfet_06v0 ad=23.584p pd=0.10808m as=13.936p ps=54.12u w=53.6u l=0.7u
X427 VSS a_2245_90628# ESD_RAIL VSS nfet_06v0 ad=13p pd=50.52u as=13p ps=50.52u w=50u l=0.7u
X428 VSS a_2245_90628# ESD_RAIL VSS nfet_06v0 ad=13p pd=50.52u as=13p ps=50.52u w=50u l=0.7u
X429 a_76544_152994_r# PAD_N__h8 VSS ppolyf_u r_width=2u r_length=4.2u
X430 ESD_RAIL a_1852_148519# VSS VSS nfet_06v0 ad=13.936p pd=54.12u as=13.936p ps=54.12u w=53.6u l=0.7u
X431 a_90880_152994# TERM_TRIM3 TERM_VCM__N22 VSS nfet_06v0 ad=5.28p pd=24.88u as=5.28p ps=24.88u w=12u l=0.7u
D64 VSS__aN PAD_N__dn diode_nd2ps_06v0 pj=51.8u area=22.5p
X432 VSS a_1852_148519# ESD_RAIL VSS nfet_06v0 ad=13.936p pd=54.12u as=13.936p ps=54.12u w=53.6u l=0.7u
D65 a_75520_93106# DVDD__sP7 diode_pd2nw_06v0 pj=4u area=1p
X433 ESD_RAIL a_1852_148519# VSS VSS nfet_06v0 ad=13.936p pd=54.12u as=23.584p ps=0.10808m w=53.6u l=0.7u
D66 VSS__aP PAD_P__dn diode_nd2ps_06v0 pj=51.8u area=22.5p
X434 VSS a_1852_148519# ESD_RAIL VSS nfet_06v0 ad=13.936p pd=54.12u as=13.936p ps=54.12u w=53.6u l=0.7u
D67 a_84736_93106# DVDD__sP16 diode_pd2nw_06v0 pj=4u area=1p
X435 a_84736_93106# TERM_TRIM2 TERM_VCM__P16 VSS nfet_06v0 ad=5.28p pd=24.88u as=5.28p ps=24.88u w=12u l=0.7u
X436 ESD_RAIL a_4789_117064# a_2245_90628# ESD_RAIL pfet_06v0 ad=2.2p pd=10.88u as=1.3p ps=5.52u w=5u l=0.7u
D68 PAD_N__up DVDD__kN diode_pd2nw_06v0 pj=51.8u area=22.5p
X437 VSS a_1852_148519# ESD_RAIL VSS nfet_06v0 ad=13.936p pd=54.12u as=13.936p ps=54.12u w=53.6u l=0.7u
X438 ESD_RAIL a_1852_148519# VSS VSS nfet_06v0 ad=13.936p pd=54.12u as=13.936p ps=54.12u w=53.6u l=0.7u
X439 VSS a_1852_148519# ESD_RAIL VSS nfet_06v0 ad=13.936p pd=54.12u as=13.936p ps=54.12u w=53.6u l=0.7u
X440 VSS a_2245_90628# ESD_RAIL VSS nfet_06v0 ad=13p pd=50.52u as=13p ps=50.52u w=50u l=0.7u
X441 RX_N__dev VDD VDD VDD pfet_06v0 ad=1.76p pd=8.88u as=1.76p ps=8.88u w=4u l=0.55u
X442 a_1005_133505# a_13878_133785# ESD_RAIL ppolyf_u r_width=0.8u r_length=63.855u
X443 VSS a_2245_90628# ESD_RAIL VSS nfet_06v0 ad=13p pd=50.52u as=13p ps=50.52u w=50u l=0.7u
D69 a_88832_93106# DVDD__sP20 diode_pd2nw_06v0 pj=4u area=1p
X444 ESD_RAIL a_1852_148519# VSS VSS nfet_06v0 ad=13.936p pd=54.12u as=13.936p ps=54.12u w=53.6u l=0.7u
X445 ESD_RAIL a_2245_90628# VSS VSS nfet_06v0 ad=13p pd=50.52u as=13p ps=50.52u w=50u l=0.7u
X446 a_90880_152994_r# PAD_N__h22 VSS ppolyf_u r_width=2u r_length=1u
X447 a_69376_152994# TERM_ENABLE TERM_VCM__N1 VSS nfet_06v0 ad=8.8p pd=40.88u as=8.8p ps=40.88u w=20u l=0.7u
X448 ESD_RAIL a_1852_148519# VSS VSS nfet_06v0 ad=13.936p pd=54.12u as=13.936p ps=54.12u w=53.6u l=0.7u
X449 ESD_RAIL a_1852_148519# VSS VSS nfet_06v0 ad=13.936p pd=54.12u as=13.936p ps=54.12u w=53.6u l=0.7u
X450 ESD_RAIL a_1852_148519# VSS VSS nfet_06v0 ad=13.936p pd=54.12u as=13.936p ps=54.12u w=53.6u l=0.7u
X451 VSS a_1852_148519# ESD_RAIL VSS nfet_06v0 ad=13.936p pd=54.12u as=13.936p ps=54.12u w=53.6u l=0.7u
X452 ESD_RAIL a_2245_90628# VSS VSS nfet_06v0 ad=13p pd=50.52u as=13p ps=50.52u w=50u l=0.7u
X453 ESD_RAIL a_1852_148519# VSS VSS nfet_06v0 ad=13.936p pd=54.12u as=23.584p ps=0.10808m w=53.6u l=0.7u
D70 a_81664_93106# DVDD__sP13 diode_pd2nw_06v0 pj=4u area=1p
X454 ESD_RAIL a_4789_117064# a_2245_90628# ESD_RAIL pfet_06v0 ad=1.3p pd=5.52u as=1.3p ps=5.52u w=5u l=0.7u
X455 a_82688_152994_r# PAD_N__h14 VSS ppolyf_u r_width=2u r_length=1u
X456 a_77568_93106# TERM_ENABLE TERM_VCM__P9 VSS nfet_06v0 ad=8.8p pd=40.88u as=8.8p ps=40.88u w=20u l=0.7u
X457 PAD_P__h0 a_68216_96594_r# VSS ppolyf_u r_width=2u r_length=4.2u
X458 ESD_RAIL a_1852_148519# VSS VSS nfet_06v0 ad=13.936p pd=54.12u as=13.936p ps=54.12u w=53.6u l=0.7u
X459 a_2245_90628# VSS VSS ppolyf_u_1k_6p0 r_width=1u r_length=99.24u
X460 VSS a_1852_148519# ESD_RAIL VSS nfet_06v0 ad=13.936p pd=54.12u as=13.936p ps=54.12u w=53.6u l=0.7u
X461 VSS a_1852_148519# ESD_RAIL VSS nfet_06v0 ad=13.936p pd=54.12u as=13.936p ps=54.12u w=53.6u l=0.7u
X462 VSS a_1852_148519# ESD_RAIL VSS nfet_06v0 ad=13.936p pd=54.12u as=13.936p ps=54.12u w=53.6u l=0.7u
X463 PAD_P__h12 a_80640_93106_r# VSS ppolyf_u r_width=2u r_length=1u
X464 VSS a_1852_148519# ESD_RAIL VSS nfet_06v0 ad=13.936p pd=54.12u as=13.936p ps=54.12u w=53.6u l=0.7u
D71 a_85760_93106# DVDD__sP17 diode_pd2nw_06v0 pj=4u area=1p
X465 a_4789_117064# a_3813_117064# VSS VSS nfet_06v0 ad=1.3p pd=5.52u as=1.3p ps=5.52u w=5u l=0.7u
X466 a_70400_93106# TERM_ENABLE TERM_VCM__P2 VSS nfet_06v0 ad=8.8p pd=40.88u as=8.8p ps=40.88u w=20u l=0.7u
X467 a_89856_152994# TERM_TRIM3 TERM_VCM__N21 VSS nfet_06v0 ad=5.28p pd=24.88u as=5.28p ps=24.88u w=12u l=0.7u
X468 RX_N__mim PAD_N__mim cap_mim_2f0_m4m5_noshield c_width=35u c_length=35u
D72 VSS ESD_RAIL diode_nd2ps_06v0 pj=82u area=40p
D73 a_75520_152994# DVDD__sN7 diode_pd2nw_06v0 pj=4u area=1p
X469 VSS a_1852_148519# ESD_RAIL VSS nfet_06v0 ad=13.936p pd=54.12u as=13.936p ps=54.12u w=53.6u l=0.7u
X470 VSS a_1852_148519# ESD_RAIL VSS nfet_06v0 ad=13.936p pd=54.12u as=13.936p ps=54.12u w=53.6u l=0.7u
X471 PAD_P__h19 a_87808_93106_r# VSS ppolyf_u r_width=2u r_length=1u
X472 VSS a_2245_90628# ESD_RAIL VSS nfet_06v0 ad=13p pd=50.52u as=13p ps=50.52u w=50u l=0.7u
X473 VSS a_1852_148519# ESD_RAIL VSS nfet_06v0 ad=13.936p pd=54.12u as=13.936p ps=54.12u w=53.6u l=0.7u
X474 ESD_RAIL a_1852_148519# VSS VSS nfet_06v0 ad=13.936p pd=54.12u as=13.936p ps=54.12u w=53.6u l=0.7u
X475 VSS a_2245_90628# ESD_RAIL VSS nfet_06v0 ad=13p pd=50.52u as=13p ps=50.52u w=50u l=0.7u
X476 VSS a_2245_90628# ESD_RAIL VSS nfet_06v0 ad=13p pd=50.52u as=13p ps=50.52u w=50u l=0.7u
X477 ESD_RAIL a_1852_148519# VSS VSS nfet_06v0 ad=13.936p pd=54.12u as=13.936p ps=54.12u w=53.6u l=0.7u
X478 a_89856_93106# TERM_TRIM3 TERM_VCM__P21 VSS nfet_06v0 ad=5.28p pd=24.88u as=5.28p ps=24.88u w=12u l=0.7u
X479 VSS a_2245_90628# ESD_RAIL VSS nfet_06v0 ad=13p pd=50.52u as=13p ps=50.52u w=50u l=0.7u
C0 a_71424_152994# TERM_VCM 2.45338f
C1 a_85760_152994# a_83712_152994# 0.0669f
C2 a_1005_133505# a_1005_134065# 0.0346f
C3 a_77568_93106# TERM_VCM 2.67274f
C4 a_91904_93106# a_89856_93106# 0.88121f
C5 TERM_TRIM2 w_71178_112088# 0.13298f
C6 VBIAS TERM_VCM 15.9004f
C7 RX_P TERM_TRIM1 0.14387f
C8 DVDD a_76544_93106# 0.99222f
C9 a_74496_152994# a_73472_152994# 0.55801f
C10 PAD_N a_75520_152994# 0.02968f
C11 TERM_ENABLE a_77568_152994# 0.41456f
C12 DVDD a_78592_93106# 1.00049f
C13 DVDD a_80640_152994# 0.99421f
C14 a_1005_133505# m2_2279_124800# 0
C15 TERM_TRIM3 a_85760_152994# 0.28938f
C16 a_75520_93106# TERM_ENABLE 0.42568f
C17 TERM_ENABLE a_76544_152994# 0.42439f
C18 a_74496_93106# TERM_ENABLE 0.42442f
C19 PAD_P a_71424_93106# 0.02968f
C20 a_88832_152994# a_86784_152994# 0.13394f
C21 PAD_P w_71178_112088# 0.48776f
C22 a_83712_152994# TERM_VCM 2.7669f
C23 DVDD a_77568_152994# 0.9869f
C24 a_91904_93106# a_88832_93106# 0.12581f
C25 PAD_N a_69376_152994# 0.02983f
C26 TERM_ENABLE a_72448_152994# 0.42916f
C27 TERM_TRIM3 a_89856_152994# 0.28932f
C28 PAD_N a_81664_152994# 0.10174f
C29 a_13878_132105# a_13878_131545# 0.0346f
C30 a_90880_152994# a_87808_152994# 0.00286f
C31 a_91904_152994# a_89856_152994# 0.88121f
C32 DVDD a_75520_93106# 0.9806f
C33 a_86784_93106# a_84736_93106# 0.10584f
C34 a_92928_93106# a_90880_93106# 0.22145f
C35 TERM_TRIM0 TERM_VCM 4.39961f
C36 DVDD a_76544_152994# 0.99222f
C37 VBIAS w_71178_112088# 1.98187f
C38 DVDD a_74496_93106# 0.97527f
C39 a_1005_132945# a_1005_133505# 0.0346f
C40 PAD_N a_73472_152994# 0.02968f
C41 a_92928_152994# a_89856_152994# 1.22348f
C42 PAD_N a_74496_152994# 0.02968f
C43 a_87808_93106# TERM_TRIM3 0.28932f
C44 VBIAS RX_N 0.24116f
C45 DVDD a_85760_152994# 0.98018f
C46 a_13878_133785# a_13878_134345# 0.0346f
C47 a_84736_152994# a_85760_152994# 1.20883f
C48 TERM_TRIM3 TERM_VCM 7.81019f
C49 a_91904_152994# TERM_VCM 2.39934f
C50 DVDD a_72448_152994# 0.97204f
C51 PAD_N a_87808_152994# 0.10174f
C52 ESD_RAIL a_13878_132665# 0.53916f
C53 a_86784_93106# a_89856_93106# 0
C54 a_80640_152994# a_79616_152994# 0.91639f
C55 a_92928_152994# TERM_VCM 2.43607f
C56 PAD_P ESD_RAIL 3.46613f
C57 TERM_ENABLE TERM_VCM 25.0657f
C58 a_70400_93106# TERM_ENABLE 0.42741f
C59 TERM_TRIM1 PAD_N 0.25684f
C60 DVDD a_89856_152994# 0.97254f
C61 PAD_N a_90880_152994# 0.10419f
C62 ESD_RAIL a_13878_133225# 0.53916f
C63 RX_P VDD 2.31443f
C64 PAD_P a_92928_93106# 0.09822f
C65 a_77568_152994# a_79616_152994# 0.01217f
C66 TERM_TRIM2 a_83712_93106# 0.28934f
C67 a_87808_93106# DVDD 0.98679f
C68 m2_2279_124800# a_1005_131825# 0
C69 PAD_P a_90880_93106# 0.10419f
C70 DVDD TERM_VCM 0.88745f
C71 TERM_TRIM2 a_81664_93106# 0.28938f
C72 a_84736_152994# TERM_VCM 2.1151f
C73 a_85760_93106# a_83712_93106# 0.0669f
C74 TERM_TRIM0 w_71178_112088# 0.14528f
C75 DVDD a_70400_93106# 0.99807f
C76 PAD_P TERM_TRIM2 0.13985f
C77 ESD_RAIL a_3813_117064# 5.25092f
C78 TERM_TRIM3 a_88832_152994# 0.28932f
C79 a_86784_93106# a_88832_93106# 0.13394f
C80 a_91904_152994# a_88832_152994# 0.12581f
C81 TERM_TRIM3 w_71178_112088# 0.15218f
C82 PAD_P a_85760_93106# 0.10174f
C83 a_68216_149604# a_69376_152994# 0.50385f
C84 a_82688_152994# a_81664_152994# 0.963f
C85 a_88832_152994# a_92928_152994# 0.34682f
C86 a_83712_93106# a_81664_93106# 0.04802f
C87 a_84736_93106# a_82688_93106# 0.06104f
C88 a_71424_93106# TERM_ENABLE 0.42933f
C89 PAD_P a_83712_93106# 0.10174f
C90 TERM_TRIM2 VBIAS 0.17974f
C91 a_77568_152994# a_75520_152994# 0.00631f
C92 TERM_ENABLE w_71178_112088# 17.179f
C93 a_4789_117064# a_1005_131545# 0.02926f
C94 a_1005_131825# a_1005_131545# 0.03725f
C95 TERM_ENABLE RX_N 0.14434f
C96 PAD_P a_81664_93106# 0.10174f
C97 a_68216_96594# TERM_VCM 2.10964f
C98 a_81664_93106# a_79616_93106# 0.03216f
C99 TERM_TRIM1 VDD 0.28454f
C100 PAD_P a_79616_93106# 0.10174f
C101 a_80640_93106# TERM_TRIM1 0.27606f
C102 DVDD a_88832_152994# 1.00598f
C103 a_76544_152994# a_75520_152994# 0.58491f
C104 DVDD a_71424_93106# 0.979f
C105 a_13878_133225# a_13878_132665# 0.0346f
C106 PAD_P a_77568_93106# 0.02968f
C107 a_81664_152994# a_80640_152994# 1.01459f
C108 m2_2279_124800# a_1005_134065# 0
C109 DVDD w_71178_112088# 1.14161f
C110 a_79616_93106# a_77568_93106# 0.01217f
C111 TERM_TRIM0 a_78592_152994# 0.27606f
C112 a_79616_152994# TERM_VCM 2.62526f
C113 TERM_TRIM2 a_83712_152994# 0.28934f
C114 PAD_P VBIAS 0.15544f
C115 a_2245_90628# a_4789_117064# 11.6307f
C116 a_70400_152994# TERM_VCM 2.34702f
C117 PAD_N VDD 0.39442f
C118 a_1005_132385# a_1005_131825# 0.0346f
C119 a_87808_93106# a_91904_93106# 0.0011f
C120 a_88832_93106# a_89856_93106# 1.12997f
C121 TERM_TRIM3 a_92928_93106# 0.27606f
C122 a_91904_93106# TERM_VCM 2.39934f
C123 TERM_TRIM2 TERM_TRIM0 0.07657f
C124 PAD_N a_82688_152994# 0.10174f
C125 TERM_TRIM3 a_90880_93106# 0.28932f
C126 TERM_ENABLE a_78592_152994# 0.00349f
C127 a_78592_93106# TERM_TRIM1 0.01326f
C128 a_68216_149604# PAD_N 0.29192f
C129 TERM_TRIM1 a_80640_152994# 0.27606f
C130 TERM_TRIM2 TERM_TRIM3 52.2297f
C131 a_75520_152994# TERM_VCM 2.53316f
C132 a_74496_152994# a_76544_152994# 0
C133 PAD_N a_1852_148519# 0.106f
C134 TERM_TRIM3 a_85760_93106# 0.28938f
C135 a_82688_93106# a_80640_93106# 0.03556f
C136 TERM_TRIM2 TERM_ENABLE 0.07746f
C137 a_72448_93106# TERM_VCM 2.44942f
C138 a_69376_93106# TERM_VCM 2.24614f
C139 DVDD a_78592_152994# 1.00049f
C140 a_70400_93106# a_69376_93106# 0.51149f
C141 m2_2279_124800# a_1005_131545# 0.05457f
C142 PAD_P TERM_TRIM0 0.11161f
C143 DVDD a_92928_93106# 0.87302f
C144 PAD_N a_80640_152994# 0.10174f
C145 a_72448_152994# a_73472_152994# 0.53659f
C146 a_1005_132945# m2_2279_124800# 0
C147 a_73472_93106# a_74496_93106# 0.55801f
C148 ESD_RAIL a_13878_131545# 0.56772f
C149 a_87808_152994# a_85760_152994# 0.11772f
C150 DVDD a_90880_93106# 0.79439f
C151 RX_P TERM_VCM 6.30872f
C152 PAD_P TERM_TRIM3 0.39826f
C153 a_77568_93106# TERM_TRIM0 0.00894f
C154 TERM_TRIM2 DVDD 0.66921f
C155 TERM_TRIM3 a_86784_152994# 0.28932f
C156 TERM_TRIM2 a_84736_152994# 0.27606f
C157 PAD_N a_77568_152994# 0.02968f
C158 VBIAS TERM_TRIM0 0.17628f
C159 a_69376_152994# TERM_VCM 2.24614f
C160 PAD_P TERM_ENABLE 0.11264f
C161 DVDD a_85760_93106# 0.98018f
C162 a_81664_152994# TERM_VCM 2.71287f
C163 TERM_TRIM3 VBIAS 4.00884f
C164 a_87808_152994# a_89856_152994# 0.21281f
C165 a_87808_93106# a_86784_93106# 1.38507f
C166 TERM_ENABLE a_71424_152994# 0.42933f
C167 DVDD a_83712_93106# 0.97117f
C168 a_73472_152994# TERM_VCM 2.44067f
C169 a_74496_152994# TERM_VCM 2.52891f
C170 a_77568_93106# TERM_ENABLE 0.41456f
C171 a_1005_132945# a_1005_131545# 0
C172 a_1005_132385# m2_2279_124800# 0
C173 PAD_N a_76544_152994# 0.02968f
C174 a_86784_93106# TERM_VCM 2.25313f
C175 a_72448_93106# a_71424_93106# 0.53348f
C176 DVDD a_81664_93106# 0.97997f
C177 VBIAS TERM_ENABLE 0.34917f
C178 PAD_N a_85760_152994# 0.10174f
C179 PAD_P DVDD 36.80691f
C180 a_87808_152994# TERM_VCM 2.16174f
C181 a_90880_152994# a_89856_152994# 0.90297f
C182 DVDD a_79616_93106# 1.01128f
C183 DVDD a_86784_152994# 0.98947f
C184 a_73472_93106# TERM_VCM 2.44067f
C185 PAD_N a_72448_152994# 0.02968f
C186 a_86784_152994# a_84736_152994# 0.10584f
C187 a_78592_152994# a_79616_152994# 0.86144f
C188 ESD_RAIL a_1005_133505# 0.53842f
C189 DVDD a_71424_152994# 0.979f
C190 TERM_TRIM1 TERM_VCM 3.78482f
C191 DVDD a_77568_93106# 0.9869f
C192 RX_P w_71178_112088# 2.17742f
C193 a_80640_93106# a_78592_93106# 0.02487f
C194 a_2245_90628# a_1005_131545# 0.01301f
C195 RX_P RX_N 3.37337f
C196 a_90880_152994# TERM_VCM 2.20446f
C197 DVDD VBIAS 0.17161f
C198 PAD_N a_89856_152994# 0.10149f
C199 a_1005_132385# a_1005_131545# 0
C200 a_87808_93106# a_84736_93106# 0
C201 a_1005_132385# a_1005_132945# 0.0346f
C202 a_82688_152994# a_80640_152994# 0.03556f
C203 a_91904_93106# a_92928_93106# 2.06022f
C204 a_84736_93106# TERM_VCM 2.1151f
C205 TERM_TRIM3 TERM_TRIM0 0.07988f
C206 PAD_P a_68216_96594# 0.29192f
C207 a_91904_93106# a_90880_93106# 2.82046f
C208 PAD_N TERM_VCM 4.83836f
C209 a_78592_93106# a_76544_93106# 0.00896f
C210 ESD_RAIL a_13878_134345# 0.5677f
C211 a_87808_93106# a_89856_93106# 0.21281f
C212 TERM_TRIM0 TERM_ENABLE 33.7009f
C213 a_88832_152994# a_87808_152994# 0.95844f
C214 TERM_TRIM3 a_91904_152994# 0.28932f
C215 a_89856_93106# TERM_VCM 2.03379f
C216 DVDD a_83712_152994# 0.97117f
C217 a_84736_152994# a_83712_152994# 1.09786f
C218 TERM_TRIM3 a_92928_152994# 0.27606f
C219 TERM_TRIM3 TERM_ENABLE 0.08127f
C220 a_91904_152994# a_92928_152994# 2.06022f
C221 TERM_TRIM1 w_71178_112088# 0.13391f
C222 a_88832_152994# a_90880_152994# 0.2912f
C223 a_82688_93106# TERM_VCM 2.1345f
C224 DVDD TERM_TRIM0 0.55616f
C225 PAD_P a_91904_93106# 0.10199f
C226 a_71424_152994# a_70400_152994# 0.52298f
C227 a_75520_93106# a_76544_93106# 0.58491f
C228 TERM_TRIM3 DVDD 5.14747f
C229 TERM_TRIM3 a_84736_152994# 0.01326f
C230 a_87808_93106# a_88832_93106# 0.95844f
C231 PAD_N a_88832_152994# 0.10174f
C232 a_76544_93106# a_74496_93106# 0
C233 DVDD a_91904_152994# 0.82057f
C234 ESD_RAIL a_4789_117064# 16.8853f
C235 TERM_TRIM2 RX_P 0.14387f
C236 ESD_RAIL a_1005_131825# 0.53823f
C237 a_88832_93106# TERM_VCM 2.00731f
C238 PAD_N w_71178_112088# 7.2118f
C239 DVDD a_92928_152994# 0.87302f
C240 DVDD TERM_ENABLE 0.55294f
C241 PAD_N RX_N 16.0706f
C242 VDD TERM_VCM 3.62756f
C243 PAD_P a_72448_93106# 0.02968f
C244 a_80640_93106# TERM_VCM 2.17853f
C245 PAD_P a_69376_93106# 0.02983f
C246 TERM_TRIM2 a_81664_152994# 0.28938f
C247 a_82688_152994# TERM_VCM 2.1345f
C248 a_77568_152994# a_76544_152994# 0.6373f
C249 a_68216_149604# TERM_VCM 2.10964f
C250 TERM_TRIM1 a_78592_152994# 0.01326f
C251 PAD_P RX_P 16.0706f
C252 DVDD a_84736_152994# 0.97492f
C253 a_86784_93106# a_85760_93106# 1.21265f
C254 TERM_ENABLE a_68216_96594# 0.42436f
C255 ESD_RAIL PAD_N 0.77975f
C256 a_75520_93106# a_74496_93106# 0.58535f
C257 a_76544_93106# TERM_VCM 2.31981f
C258 TERM_TRIM2 TERM_TRIM1 49.1143f
C259 RX_P VBIAS 0.079f
C260 a_78592_93106# TERM_VCM 2.24159f
C261 ESD_RAIL a_1005_134065# 0.57348f
C262 a_80640_152994# TERM_VCM 2.17853f
C263 PAD_N a_78592_152994# 0.10174f
C264 PAD_P a_86784_93106# 0.10174f
C265 VDD w_71178_112088# 5.53293f
C266 TERM_TRIM2 a_84736_93106# 0.27606f
C267 VDD RX_N 8.13768f
C268 DVDD a_68216_96594# 0.97412f
C269 TERM_TRIM3 a_91904_93106# 0.28932f
C270 a_92928_93106# a_89856_93106# 1.22348f
C271 TERM_ENABLE a_70400_152994# 0.42741f
C272 a_77568_152994# TERM_VCM 2.67274f
C273 a_86784_152994# a_87808_152994# 1.38507f
C274 PAD_P a_73472_93106# 0.02968f
C275 a_84736_93106# a_85760_93106# 1.20883f
C276 TERM_TRIM2 PAD_N 0.25684f
C277 ESD_RAIL m2_2279_124800# 5.47988f
C278 a_90880_93106# a_89856_93106# 0.90297f
C279 PAD_P TERM_TRIM1 0.11203f
C280 ESD_RAIL a_13878_133785# 0.53942f
C281 a_84736_93106# a_83712_93106# 1.09786f
C282 TERM_TRIM1 a_79616_93106# 0.28933f
C283 a_75520_93106# TERM_VCM 2.53316f
C284 DVDD a_79616_152994# 1.01128f
C285 a_76544_152994# TERM_VCM 2.31981f
C286 a_74496_93106# TERM_VCM 2.52891f
C287 DVDD a_70400_152994# 0.99807f
C288 a_3813_117064# a_4789_117064# 3.03168f
C289 PAD_P a_84736_93106# 0.10174f
C290 a_85760_152994# TERM_VCM 2.80748f
C291 a_83712_152994# a_81664_152994# 0.04802f
C292 TERM_ENABLE a_75520_152994# 0.42568f
C293 RX_P TERM_TRIM0 0.16216f
C294 TERM_TRIM1 VBIAS 0.17732f
C295 TERM_TRIM2 a_82688_93106# 0.28932f
C296 DVDD a_91904_93106# 0.82057f
C297 a_72448_93106# TERM_ENABLE 0.42916f
C298 a_72448_152994# TERM_VCM 2.44942f
C299 PAD_P PAD_N 16.6709f
C300 ESD_RAIL a_1005_131545# 97.1325f
C301 TERM_ENABLE a_69376_93106# 0.4257f
C302 a_92928_93106# a_88832_93106# 0.34682f
C303 PAD_N a_86784_152994# 0.10174f
C304 TERM_TRIM3 RX_P 0.14387f
C305 ESD_RAIL a_1005_132945# 0.53823f
C306 PAD_N a_71424_152994# 0.02968f
C307 PAD_P a_89856_93106# 0.10149f
C308 a_90880_93106# a_88832_93106# 0.2912f
C309 a_82688_93106# a_83712_93106# 1.15414f
C310 a_89856_152994# TERM_VCM 2.03379f
C311 RX_P TERM_ENABLE 0
C312 DVDD a_75520_152994# 0.9806f
C313 VBIAS PAD_N 0.15966f
C314 a_82688_93106# a_81664_93106# 0.963f
C315 DVDD a_72448_93106# 0.97204f
C316 a_87808_93106# TERM_VCM 2.16174f
C317 ESD_RAIL a_1852_148519# 0.33756p
C318 TERM_TRIM2 VDD 0.28557f
C319 PAD_P a_82688_93106# 0.10174f
C320 DVDD a_69376_93106# 1.00706f
C321 a_85760_93106# a_88832_93106# 0
C322 TERM_ENABLE a_69376_152994# 0.4257f
C323 TERM_TRIM2 a_80640_93106# 0.01326f
C324 ESD_RAIL a_2245_90628# 0.24349p
C325 TERM_TRIM3 a_86784_93106# 0.28932f
C326 a_70400_93106# TERM_VCM 2.34702f
C327 a_88832_152994# a_85760_152994# 0
C328 ESD_RAIL a_1005_132385# 0.53823f
C329 TERM_TRIM2 a_82688_152994# 0.28932f
C330 TERM_ENABLE a_73472_152994# 0.42888f
C331 TERM_TRIM1 TERM_TRIM0 47.3852f
C332 TERM_ENABLE a_74496_152994# 0.42442f
C333 TERM_TRIM3 a_87808_152994# 0.28932f
C334 ESD_RAIL a_13878_132105# 0.53942f
C335 a_91904_152994# a_87808_152994# 0.0011f
C336 a_78592_152994# a_80640_152994# 0.02487f
C337 PAD_N a_83712_152994# 0.10174f
C338 PAD_P a_88832_93106# 0.10174f
C339 a_13878_133785# a_13878_133225# 0.0346f
C340 a_92928_152994# a_87808_152994# 0.01199f
C341 TERM_TRIM3 TERM_TRIM1 0.08733f
C342 DVDD a_69376_152994# 1.00706f
C343 a_80640_93106# a_81664_93106# 1.01459f
C344 PAD_P VDD 0.39442f
C345 DVDD a_81664_152994# 0.97997f
C346 a_88832_152994# a_89856_152994# 1.12997f
C347 a_73472_93106# TERM_ENABLE 0.42888f
C348 a_68216_96594# a_69376_93106# 0.50385f
C349 TERM_TRIM3 a_90880_152994# 0.28932f
C350 PAD_P a_80640_93106# 0.10174f
C351 a_91904_152994# a_90880_152994# 2.82046f
C352 DVDD a_73472_152994# 0.97065f
C353 TERM_TRIM1 TERM_ENABLE 0.09198f
C354 a_80640_93106# a_79616_93106# 0.91639f
C355 DVDD a_74496_152994# 0.97527f
C356 a_78592_152994# a_77568_152994# 0.61569f
C357 TERM_TRIM0 PAD_N 0.25684f
C358 TERM_TRIM2 a_80640_152994# 0.01326f
C359 a_90880_152994# a_92928_152994# 0.22145f
C360 DVDD a_86784_93106# 0.98947f
C361 TERM_TRIM3 a_84736_93106# 0.01326f
C362 a_88832_152994# TERM_VCM 2.00731f
C363 VBIAS VDD 6.80037f
C364 a_71424_93106# TERM_VCM 2.45338f
C365 DVDD a_87808_152994# 0.98679f
C366 TERM_TRIM3 PAD_N 0.35588f
C367 a_84736_152994# a_87808_152994# 0
C368 w_71178_112088# TERM_VCM 0.37908f
C369 a_70400_93106# a_71424_93106# 0.52298f
C370 PAD_N a_91904_152994# 0.10199f
C371 a_73472_93106# DVDD 0.97065f
C372 RX_N TERM_VCM 6.84313f
C373 a_78592_152994# a_76544_152994# 0.00896f
C374 PAD_P a_1852_148519# 0.25621f
C375 PAD_N a_92928_152994# 0.09822f
C376 DVDD TERM_TRIM1 0.60038f
C377 PAD_P a_76544_93106# 0.02968f
C378 TERM_TRIM3 a_89856_93106# 0.28932f
C379 PAD_N TERM_ENABLE 0.33094f
C380 DVDD a_90880_152994# 0.79439f
C381 a_3813_117064# a_1005_131545# 2.44008f
C382 PAD_P a_78592_93106# 0.10174f
C383 a_78592_93106# a_79616_93106# 0.86144f
C384 a_77568_93106# a_76544_93106# 0.6373f
C385 DVDD a_84736_93106# 0.97492f
C386 a_13878_132665# a_13878_132105# 0.0346f
C387 a_78592_93106# a_77568_93106# 0.61569f
C388 a_81664_152994# a_79616_152994# 0.03216f
C389 a_69376_152994# a_70400_152994# 0.51149f
C390 DVDD PAD_N 62.6347f
C391 PAD_N a_84736_152994# 0.10174f
C392 a_83712_152994# a_82688_152994# 1.15414f
C393 TERM_TRIM0 VDD 0.28403f
C394 a_2245_90628# a_3813_117064# 0.00994f
C395 DVDD a_89856_93106# 0.97254f
C396 TERM_TRIM3 a_88832_93106# 0.28932f
C397 a_87808_93106# a_92928_93106# 0.01199f
C398 a_78592_152994# TERM_VCM 2.24159f
C399 PAD_P a_75520_93106# 0.02968f
C400 w_71178_112088# RX_N 2.17714f
C401 a_92928_93106# TERM_VCM 2.43607f
C402 TERM_TRIM3 VDD 4.05215f
C403 PAD_P a_74496_93106# 0.02968f
C404 a_87808_93106# a_90880_93106# 0.00286f
C405 DVDD a_82688_93106# 0.9704f
C406 TERM_TRIM1 a_79616_152994# 0.28933f
C407 a_90880_93106# TERM_VCM 2.20446f
C408 a_75520_93106# a_77568_93106# 0.00631f
C409 a_86784_152994# a_85760_152994# 1.21265f
C410 TERM_ENABLE VDD 12.9618f
C411 TERM_TRIM2 TERM_VCM 5.12464f
C412 a_87808_93106# a_85760_93106# 0.11772f
C413 a_74496_152994# a_75520_152994# 0.58535f
C414 a_85760_93106# TERM_VCM 2.80748f
C415 a_71424_152994# a_72448_152994# 0.53348f
C416 a_68216_149604# TERM_ENABLE 0.42436f
C417 DVDD a_88832_93106# 1.00598f
C418 a_78592_93106# TERM_TRIM0 0.27606f
C419 a_83712_93106# TERM_VCM 2.7669f
C420 a_86784_152994# a_89856_152994# 0
C421 ESD_RAIL w_71178_112088# 0.08713f
C422 PAD_N a_79616_152994# 0.10174f
C423 DVDD VDD 10.3757f
C424 PAD_P a_87808_93106# 0.10174f
C425 PAD_N a_70400_152994# 0.02968f
C426 DVDD a_80640_93106# 0.99421f
C427 a_81664_93106# TERM_VCM 2.71287f
C428 a_73472_93106# a_72448_93106# 0.53659f
C429 a_76544_93106# TERM_ENABLE 0.42439f
C430 PAD_P TERM_VCM 4.45493f
C431 DVDD a_82688_152994# 0.9704f
C432 a_84736_152994# a_82688_152994# 0.06104f
C433 TERM_TRIM0 a_77568_152994# 0.00894f
C434 a_79616_93106# TERM_VCM 2.62526f
C435 PAD_P a_70400_93106# 0.02968f
C436 a_86784_152994# TERM_VCM 2.25313f
C437 DVDD a_68216_149604# 0.97412f
C438 a_78592_93106# TERM_ENABLE 0.00349f
C439 PAD_P VSS 0.47045p
C440 RX_P VSS 43.3925f
C441 VBIAS VSS 8.63568f
C442 RX_N VSS 37.5198f
C443 PAD_N VSS 0.43016p
C444 TERM_TRIM3 VSS 60.4428f
C445 TERM_TRIM2 VSS 21.139f
C446 TERM_TRIM1 VSS 13.3581f
C447 TERM_TRIM0 VSS 13.2893f
C448 TERM_VCM VSS 0.29884p
C449 TERM_ENABLE VSS 41.6599f
C450 DVDD VSS 0.466p
C451 VDD VSS 27.6088f
C452 ESD_RAIL VSS 2.87455p
C453 m2_2279_124800# VSS 7.46506f $ **FLOATING
C454 a_92928_93106# VSS 6.8905f
C455 a_91904_93106# VSS 5.17199f
C456 a_90880_93106# VSS 6.12432f
C457 a_89856_93106# VSS 5.80315f
C458 a_88832_93106# VSS 7.21276f
C459 a_87808_93106# VSS 6.85766f
C460 a_86784_93106# VSS 6.67282f
C461 a_85760_93106# VSS 6.15535f
C462 a_84736_93106# VSS 6.75134f
C463 a_83712_93106# VSS 6.18878f
C464 a_82688_93106# VSS 6.6628f
C465 a_81664_93106# VSS 6.19982f
C466 a_80640_93106# VSS 6.57327f
C467 a_79616_93106# VSS 6.2116f
C468 a_78592_93106# VSS 6.50305f
C469 a_77568_93106# VSS 6.86875f
C470 a_76544_93106# VSS 6.92071f
C471 a_75520_93106# VSS 6.83431f
C472 a_74496_93106# VSS 6.82804f
C473 a_73472_93106# VSS 6.6374f
C474 a_72448_93106# VSS 6.60695f
C475 a_71424_93106# VSS 6.56669f
C476 a_70400_93106# VSS 6.39551f
C477 a_69376_93106# VSS 6.24082f
C478 a_68216_96594# VSS 6.64343f
C479 a_2245_90628# VSS 0.24972p
C480 a_4789_117064# VSS 8.91806f
C481 a_3813_117064# VSS 5.17875f
C482 a_1005_131545# VSS 98.15211f
C483 a_13878_131545# VSS 0.07835f
C484 a_1005_131825# VSS 0.07377f
C485 a_13878_132105# VSS 0.07394f
C486 a_1005_132385# VSS 0.07377f
C487 a_13878_132665# VSS 0.07394f
C488 a_1005_132945# VSS 0.07377f
C489 a_13878_133225# VSS 0.07394f
C490 a_1005_133505# VSS 0.07377f
C491 a_13878_133785# VSS 0.07394f
C492 a_1005_134065# VSS 0.07377f
C493 a_13878_134345# VSS 0.07838f
C494 a_92928_152994# VSS 6.8905f
C495 a_91904_152994# VSS 5.17199f
C496 a_90880_152994# VSS 6.12432f
C497 a_89856_152994# VSS 5.80315f
C498 a_88832_152994# VSS 7.21276f
C499 a_87808_152994# VSS 6.85766f
C500 a_86784_152994# VSS 6.67282f
C501 a_85760_152994# VSS 6.15535f
C502 a_84736_152994# VSS 6.75134f
C503 a_83712_152994# VSS 6.18878f
C504 a_82688_152994# VSS 6.6628f
C505 a_81664_152994# VSS 6.19982f
C506 a_80640_152994# VSS 6.57327f
C507 a_79616_152994# VSS 6.2116f
C508 a_78592_152994# VSS 6.50305f
C509 a_77568_152994# VSS 6.86875f
C510 a_76544_152994# VSS 6.92071f
C511 a_75520_152994# VSS 6.83431f
C512 a_74496_152994# VSS 6.82804f
C513 a_73472_152994# VSS 6.6374f
C514 a_72448_152994# VSS 6.60695f
C515 a_71424_152994# VSS 6.56669f
C516 a_70400_152994# VSS 6.39551f
C517 a_69376_152994# VSS 6.24082f
C518 a_68216_149604# VSS 6.64343f
C519 a_1852_148519# VSS 0.41778p
C520 w_71178_112088# VSS 50.5532f
* netres.py resistances (high metal): 3428 resistors, res/a6.json res/a6_tu.json
RNR0 TERM_VCM TERM_VCM__P0 162.307
RNR1 TERM_VCM TERM_VCM__P1 161.537
RNR2 TERM_VCM TERM_VCM__P2 160.257
RNR3 TERM_VCM TERM_VCM__P3 158.374
RNR4 TERM_VCM TERM_VCM__P4 156.024
RNR5 TERM_VCM TERM_VCM__P5 153.074
RNR6 TERM_VCM TERM_VCM__P6 149.774
RNR7 TERM_VCM TERM_VCM__P7 146.077
RNR8 TERM_VCM TERM_VCM__P8 141.88
RNR9 TERM_VCM TERM_VCM__P9 137.541
RNR10 TERM_VCM TERM_VCM__P10 134.057
RNR11 TERM_VCM TERM_VCM__P11 129.161
RNR12 TERM_VCM TERM_VCM__P12 124.292
RNR13 TERM_VCM TERM_VCM__P13 119.334
RNR14 TERM_VCM TERM_VCM__P14 114.165
RNR15 TERM_VCM TERM_VCM__P15 109.198
RNR16 TERM_VCM TERM_VCM__P16 104.098
RNR17 TERM_VCM TERM_VCM__P17 99.2601
RNR18 TERM_VCM TERM_VCM__P18 94.5237
RNR19 TERM_VCM TERM_VCM__P19 89.7462
RNR20 TERM_VCM TERM_VCM__P20 85.3042
RNR21 TERM_VCM TERM_VCM__P21 81.0398
RNR22 TERM_VCM TERM_VCM__P22 76.8512
RNR23 TERM_VCM TERM_VCM__P23 73.1211
RNR24 TERM_VCM TERM_VCM__P24 69.8063
RNR25 TERM_VCM TERM_VCM__N0 162.289
RNR26 TERM_VCM TERM_VCM__N1 161.52
RNR27 TERM_VCM TERM_VCM__N2 160.239
RNR28 TERM_VCM TERM_VCM__N3 158.356
RNR29 TERM_VCM TERM_VCM__N4 156.007
RNR30 TERM_VCM TERM_VCM__N5 153.058
RNR31 TERM_VCM TERM_VCM__N6 149.758
RNR32 TERM_VCM TERM_VCM__N7 146.061
RNR33 TERM_VCM TERM_VCM__N8 141.865
RNR34 TERM_VCM TERM_VCM__N9 137.526
RNR35 TERM_VCM TERM_VCM__N10 134.031
RNR36 TERM_VCM TERM_VCM__N11 129.136
RNR37 TERM_VCM TERM_VCM__N12 124.268
RNR38 TERM_VCM TERM_VCM__N13 119.311
RNR39 TERM_VCM TERM_VCM__N14 114.143
RNR40 TERM_VCM TERM_VCM__N15 109.176
RNR41 TERM_VCM TERM_VCM__N16 104.077
RNR42 TERM_VCM TERM_VCM__N17 99.2404
RNR43 TERM_VCM TERM_VCM__N18 94.5048
RNR44 TERM_VCM TERM_VCM__N19 89.7281
RNR45 TERM_VCM TERM_VCM__N20 85.2869
RNR46 TERM_VCM TERM_VCM__N21 81.0231
RNR47 TERM_VCM TERM_VCM__N22 76.8353
RNR48 TERM_VCM TERM_VCM__N23 73.1058
RNR49 TERM_VCM TERM_VCM__N24 69.7914
RNR50 TERM_VCM__P0 TERM_VCM__P1 116.305
RNR51 TERM_VCM__P0 TERM_VCM__P2 125.164
RNR52 TERM_VCM__P0 TERM_VCM__P3 133.892
RNR53 TERM_VCM__P0 TERM_VCM__P4 142.369
RNR54 TERM_VCM__P0 TERM_VCM__P5 151.333
RNR55 TERM_VCM__P0 TERM_VCM__P6 160.281
RNR56 TERM_VCM__P0 TERM_VCM__P7 169.545
RNR57 TERM_VCM__P0 TERM_VCM__P8 179.521
RNR58 TERM_VCM__P0 TERM_VCM__P9 189.504
RNR59 TERM_VCM__P0 TERM_VCM__P10 201.456
RNR60 TERM_VCM__P0 TERM_VCM__P11 212.734
RNR61 TERM_VCM__P0 TERM_VCM__P12 223.919
RNR62 TERM_VCM__P0 TERM_VCM__P13 235.372
RNR63 TERM_VCM__P0 TERM_VCM__P14 247.534
RNR64 TERM_VCM__P0 TERM_VCM__P15 259.485
RNR65 TERM_VCM__P0 TERM_VCM__P16 272.045
RNR66 TERM_VCM__P0 TERM_VCM__P17 284.23
RNR67 TERM_VCM__P0 TERM_VCM__P18 296.393
RNR68 TERM_VCM__P0 TERM_VCM__P19 308.885
RNR69 TERM_VCM__P0 TERM_VCM__P20 320.694
RNR70 TERM_VCM__P0 TERM_VCM__P21 332.088
RNR71 TERM_VCM__P0 TERM_VCM__P22 343.312
RNR72 TERM_VCM__P0 TERM_VCM__P23 353.268
RNR73 TERM_VCM__P0 TERM_VCM__P24 361.895
RNR74 TERM_VCM__P0 TERM_VCM__N0 2495.21
RNR75 TERM_VCM__P0 TERM_VCM__N1 2580.5
RNR76 TERM_VCM__P0 TERM_VCM__N2 2626.52
RNR77 TERM_VCM__P0 TERM_VCM__N3 2645.43
RNR78 TERM_VCM__P0 TERM_VCM__N4 2645.38
RNR79 TERM_VCM__P0 TERM_VCM__N5 2629.51
RNR80 TERM_VCM__P0 TERM_VCM__N6 2602.21
RNR81 TERM_VCM__P0 TERM_VCM__N7 2564.53
RNR82 TERM_VCM__P0 TERM_VCM__N8 2515.97
RNR83 TERM_VCM__P0 TERM_VCM__N9 2461.22
RNR84 TERM_VCM__P0 TERM_VCM__N10 2419.14
RNR85 TERM_VCM__P0 TERM_VCM__N11 2350
RNR86 TERM_VCM__P0 TERM_VCM__N12 2278.16
RNR87 TERM_VCM__P0 TERM_VCM__N13 2202.34
RNR88 TERM_VCM__P0 TERM_VCM__N14 2120.82
RNR89 TERM_VCM__P0 TERM_VCM__N15 2040.4
RNR90 TERM_VCM__P0 TERM_VCM__N16 1955.9
RNR91 TERM_VCM__P0 TERM_VCM__N17 1874.11
RNR92 TERM_VCM__P0 TERM_VCM__N18 1792.63
RNR93 TERM_VCM__P0 TERM_VCM__N19 1709.14
RNR94 TERM_VCM__P0 TERM_VCM__N20 1630.44
RNR95 TERM_VCM__P0 TERM_VCM__N21 1553.98
RNR96 TERM_VCM__P0 TERM_VCM__N22 1478.09
RNR97 TERM_VCM__P0 TERM_VCM__N23 1409.88
RNR98 TERM_VCM__P0 TERM_VCM__N24 1348.8
RNR99 TERM_VCM__P1 TERM_VCM__P2 123.669
RNR100 TERM_VCM__P1 TERM_VCM__P3 132.71
RNR101 TERM_VCM__P1 TERM_VCM__P4 141.303
RNR102 TERM_VCM__P1 TERM_VCM__P5 150.303
RNR103 TERM_VCM__P1 TERM_VCM__P6 159.249
RNR104 TERM_VCM__P1 TERM_VCM__P7 168.488
RNR105 TERM_VCM__P1 TERM_VCM__P8 178.423
RNR106 TERM_VCM__P1 TERM_VCM__P9 188.359
RNR107 TERM_VCM__P1 TERM_VCM__P10 200.25
RNR108 TERM_VCM__P1 TERM_VCM__P11 211.465
RNR109 TERM_VCM__P1 TERM_VCM__P12 222.587
RNR110 TERM_VCM__P1 TERM_VCM__P13 233.977
RNR111 TERM_VCM__P1 TERM_VCM__P14 246.071
RNR112 TERM_VCM__P1 TERM_VCM__P15 257.955
RNR113 TERM_VCM__P1 TERM_VCM__P16 270.445
RNR114 TERM_VCM__P1 TERM_VCM__P17 282.564
RNR115 TERM_VCM__P1 TERM_VCM__P18 294.661
RNR116 TERM_VCM__P1 TERM_VCM__P19 307.086
RNR117 TERM_VCM__P1 TERM_VCM__P20 318.833
RNR118 TERM_VCM__P1 TERM_VCM__P21 330.168
RNR119 TERM_VCM__P1 TERM_VCM__P22 341.336
RNR120 TERM_VCM__P1 TERM_VCM__P23 351.243
RNR121 TERM_VCM__P1 TERM_VCM__P24 359.829
RNR122 TERM_VCM__P1 TERM_VCM__N0 2580.49
RNR123 TERM_VCM__P1 TERM_VCM__N1 2654.42
RNR124 TERM_VCM__P1 TERM_VCM__N2 2691.82
RNR125 TERM_VCM__P1 TERM_VCM__N3 2703.67
RNR126 TERM_VCM__P1 TERM_VCM__N4 2697.62
RNR127 TERM_VCM__P1 TERM_VCM__N5 2676.17
RNR128 TERM_VCM__P1 TERM_VCM__N6 2643.82
RNR129 TERM_VCM__P1 TERM_VCM__N7 2601.38
RNR130 TERM_VCM__P1 TERM_VCM__N8 2548.16
RNR131 TERM_VCM__P1 TERM_VCM__N9 2489.19
RNR132 TERM_VCM__P1 TERM_VCM__N10 2443.37
RNR133 TERM_VCM__P1 TERM_VCM__N11 2370.45
RNR134 TERM_VCM__P1 TERM_VCM__N12 2295.29
RNR135 TERM_VCM__P1 TERM_VCM__N13 2216.46
RNR136 TERM_VCM__P1 TERM_VCM__N14 2132.16
RNR137 TERM_VCM__P1 TERM_VCM__N15 2049.37
RNR138 TERM_VCM__P1 TERM_VCM__N16 1962.74
RNR139 TERM_VCM__P1 TERM_VCM__N17 1879.16
RNR140 TERM_VCM__P1 TERM_VCM__N18 1796.15
RNR141 TERM_VCM__P1 TERM_VCM__N19 1711.32
RNR142 TERM_VCM__P1 TERM_VCM__N20 1631.54
RNR143 TERM_VCM__P1 TERM_VCM__N21 1554.19
RNR144 TERM_VCM__P1 TERM_VCM__N22 1477.55
RNR145 TERM_VCM__P1 TERM_VCM__N23 1408.78
RNR146 TERM_VCM__P1 TERM_VCM__N24 1347.27
RNR147 TERM_VCM__P2 TERM_VCM__P3 130.34
RNR148 TERM_VCM__P2 TERM_VCM__P4 139.426
RNR149 TERM_VCM__P2 TERM_VCM__P5 148.621
RNR150 TERM_VCM__P2 TERM_VCM__P6 157.644
RNR151 TERM_VCM__P2 TERM_VCM__P7 166.891
RNR152 TERM_VCM__P2 TERM_VCM__P8 176.791
RNR153 TERM_VCM__P2 TERM_VCM__P9 186.672
RNR154 TERM_VCM__P2 TERM_VCM__P10 198.483
RNR155 TERM_VCM__P2 TERM_VCM__P11 209.612
RNR156 TERM_VCM__P2 TERM_VCM__P12 220.644
RNR157 TERM_VCM__P2 TERM_VCM__P13 231.939
RNR158 TERM_VCM__P2 TERM_VCM__P14 243.932
RNR159 TERM_VCM__P2 TERM_VCM__P15 255.717
RNR160 TERM_VCM__P2 TERM_VCM__P16 268.102
RNR161 TERM_VCM__P2 TERM_VCM__P17 280.12
RNR162 TERM_VCM__P2 TERM_VCM__P18 292.115
RNR163 TERM_VCM__P2 TERM_VCM__P19 304.438
RNR164 TERM_VCM__P2 TERM_VCM__P20 316.087
RNR165 TERM_VCM__P2 TERM_VCM__P21 327.33
RNR166 TERM_VCM__P2 TERM_VCM__P22 338.407
RNR167 TERM_VCM__P2 TERM_VCM__P23 348.235
RNR168 TERM_VCM__P2 TERM_VCM__P24 356.753
RNR169 TERM_VCM__P2 TERM_VCM__N0 2626.52
RNR170 TERM_VCM__P2 TERM_VCM__N1 2691.82
RNR171 TERM_VCM__P2 TERM_VCM__N2 2722.91
RNR172 TERM_VCM__P2 TERM_VCM__N3 2729.74
RNR173 TERM_VCM__P2 TERM_VCM__N4 2719.56
RNR174 TERM_VCM__P2 TERM_VCM__N5 2694.36
RNR175 TERM_VCM__P2 TERM_VCM__N6 2658.71
RNR176 TERM_VCM__P2 TERM_VCM__N7 2613.23
RNR177 TERM_VCM__P2 TERM_VCM__N8 2557.13
RNR178 TERM_VCM__P2 TERM_VCM__N9 2495.6
RNR179 TERM_VCM__P2 TERM_VCM__N10 2447.49
RNR180 TERM_VCM__P2 TERM_VCM__N11 2372.41
RNR181 TERM_VCM__P2 TERM_VCM__N12 2295.4
RNR182 TERM_VCM__P2 TERM_VCM__N13 2214.96
RNR183 TERM_VCM__P2 TERM_VCM__N14 2129.23
RNR184 TERM_VCM__P2 TERM_VCM__N15 2045.29
RNR185 TERM_VCM__P2 TERM_VCM__N16 1957.67
RNR186 TERM_VCM__P2 TERM_VCM__N17 1873.33
RNR187 TERM_VCM__P2 TERM_VCM__N18 1789.72
RNR188 TERM_VCM__P2 TERM_VCM__N19 1704.42
RNR189 TERM_VCM__P2 TERM_VCM__N20 1624.33
RNR190 TERM_VCM__P2 TERM_VCM__N21 1546.78
RNR191 TERM_VCM__P2 TERM_VCM__N22 1470.03
RNR192 TERM_VCM__P2 TERM_VCM__N23 1401.23
RNR193 TERM_VCM__P2 TERM_VCM__N24 1339.74
RNR194 TERM_VCM__P3 TERM_VCM__P4 136.257
RNR195 TERM_VCM__P3 TERM_VCM__P5 146.015
RNR196 TERM_VCM__P3 TERM_VCM__P6 155.262
RNR197 TERM_VCM__P3 TERM_VCM__P7 164.577
RNR198 TERM_VCM__P3 TERM_VCM__P8 174.459
RNR199 TERM_VCM__P3 TERM_VCM__P9 184.282
RNR200 TERM_VCM__P3 TERM_VCM__P10 195.994
RNR201 TERM_VCM__P3 TERM_VCM__P11 207.005
RNR202 TERM_VCM__P3 TERM_VCM__P12 217.914
RNR203 TERM_VCM__P3 TERM_VCM__P13 229.078
RNR204 TERM_VCM__P3 TERM_VCM__P14 240.928
RNR205 TERM_VCM__P3 TERM_VCM__P15 252.572
RNR206 TERM_VCM__P3 TERM_VCM__P16 264.809
RNR207 TERM_VCM__P3 TERM_VCM__P17 276.682
RNR208 TERM_VCM__P3 TERM_VCM__P18 288.533
RNR209 TERM_VCM__P3 TERM_VCM__P19 300.708
RNR210 TERM_VCM__P3 TERM_VCM__P20 312.217
RNR211 TERM_VCM__P3 TERM_VCM__P21 323.326
RNR212 TERM_VCM__P3 TERM_VCM__P22 334.272
RNR213 TERM_VCM__P3 TERM_VCM__P23 343.983
RNR214 TERM_VCM__P3 TERM_VCM__P24 352.401
RNR215 TERM_VCM__P3 TERM_VCM__N0 2645.43
RNR216 TERM_VCM__P3 TERM_VCM__N1 2703.67
RNR217 TERM_VCM__P3 TERM_VCM__N2 2729.73
RNR218 TERM_VCM__P3 TERM_VCM__N3 2732.72
RNR219 TERM_VCM__P3 TERM_VCM__N4 2719.49
RNR220 TERM_VCM__P3 TERM_VCM__N5 2691.64
RNR221 TERM_VCM__P3 TERM_VCM__N6 2653.75
RNR222 TERM_VCM__P3 TERM_VCM__N7 2606.29
RNR223 TERM_VCM__P3 TERM_VCM__N8 2548.38
RNR224 TERM_VCM__P3 TERM_VCM__N9 2485.34
RNR225 TERM_VCM__P3 TERM_VCM__N10 2435.84
RNR226 TERM_VCM__P3 TERM_VCM__N11 2359.62
RNR227 TERM_VCM__P3 TERM_VCM__N12 2281.72
RNR228 TERM_VCM__P3 TERM_VCM__N13 2200.58
RNR229 TERM_VCM__P3 TERM_VCM__N14 2114.34
RNR230 TERM_VCM__P3 TERM_VCM__N15 2030.05
RNR231 TERM_VCM__P3 TERM_VCM__N16 1942.24
RNR232 TERM_VCM__P3 TERM_VCM__N17 1857.86
RNR233 TERM_VCM__P3 TERM_VCM__N18 1774.32
RNR234 TERM_VCM__P3 TERM_VCM__N19 1689.21
RNR235 TERM_VCM__P3 TERM_VCM__N20 1609.37
RNR236 TERM_VCM__P3 TERM_VCM__N21 1532.14
RNR237 TERM_VCM__P3 TERM_VCM__N22 1455.77
RNR238 TERM_VCM__P3 TERM_VCM__N23 1387.36
RNR239 TERM_VCM__P3 TERM_VCM__N24 1326.26
RNR240 TERM_VCM__P4 TERM_VCM__P5 142.181
RNR241 TERM_VCM__P4 TERM_VCM__P6 152.031
RNR242 TERM_VCM__P4 TERM_VCM__P7 161.572
RNR243 TERM_VCM__P4 TERM_VCM__P8 171.505
RNR244 TERM_VCM__P4 TERM_VCM__P9 181.297
RNR245 TERM_VCM__P4 TERM_VCM__P10 192.914
RNR246 TERM_VCM__P4 TERM_VCM__P11 203.793
RNR247 TERM_VCM__P4 TERM_VCM__P12 214.558
RNR248 TERM_VCM__P4 TERM_VCM__P13 225.565
RNR249 TERM_VCM__P4 TERM_VCM__P14 237.243
RNR250 TERM_VCM__P4 TERM_VCM__P15 248.715
RNR251 TERM_VCM__P4 TERM_VCM__P16 260.769
RNR252 TERM_VCM__P4 TERM_VCM__P17 272.464
RNR253 TERM_VCM__P4 TERM_VCM__P18 284.138
RNR254 TERM_VCM__P4 TERM_VCM__P19 296.13
RNR255 TERM_VCM__P4 TERM_VCM__P20 307.467
RNR256 TERM_VCM__P4 TERM_VCM__P21 318.41
RNR257 TERM_VCM__P4 TERM_VCM__P22 329.192
RNR258 TERM_VCM__P4 TERM_VCM__P23 338.759
RNR259 TERM_VCM__P4 TERM_VCM__P24 347.052
RNR260 TERM_VCM__P4 TERM_VCM__N0 2645.38
RNR261 TERM_VCM__P4 TERM_VCM__N1 2697.62
RNR262 TERM_VCM__P4 TERM_VCM__N2 2719.55
RNR263 TERM_VCM__P4 TERM_VCM__N3 2719.49
RNR264 TERM_VCM__P4 TERM_VCM__N4 2703.93
RNR265 TERM_VCM__P4 TERM_VCM__N5 2674.17
RNR266 TERM_VCM__P4 TERM_VCM__N6 2634.74
RNR267 TERM_VCM__P4 TERM_VCM__N7 2586.01
RNR268 TERM_VCM__P4 TERM_VCM__N8 2527.03
RNR269 TERM_VCM__P4 TERM_VCM__N9 2463.18
RNR270 TERM_VCM__P4 TERM_VCM__N10 2412.88
RNR271 TERM_VCM__P4 TERM_VCM__N11 2336.22
RNR272 TERM_VCM__P4 TERM_VCM__N12 2258.09
RNR273 TERM_VCM__P4 TERM_VCM__N13 2176.89
RNR274 TERM_VCM__P4 TERM_VCM__N14 2090.74
RNR275 TERM_VCM__P4 TERM_VCM__N15 2006.69
RNR276 TERM_VCM__P4 TERM_VCM__N16 1919.24
RNR277 TERM_VCM__P4 TERM_VCM__N17 1835.31
RNR278 TERM_VCM__P4 TERM_VCM__N18 1752.31
RNR279 TERM_VCM__P4 TERM_VCM__N19 1667.83
RNR280 TERM_VCM__P4 TERM_VCM__N20 1588.65
RNR281 TERM_VCM__P4 TERM_VCM__N21 1512.11
RNR282 TERM_VCM__P4 TERM_VCM__N22 1436.48
RNR283 TERM_VCM__P4 TERM_VCM__N23 1368.76
RNR284 TERM_VCM__P4 TERM_VCM__N24 1308.32
RNR285 TERM_VCM__P5 TERM_VCM__P6 147.377
RNR286 TERM_VCM__P5 TERM_VCM__P7 157.538
RNR287 TERM_VCM__P5 TERM_VCM__P8 167.673
RNR288 TERM_VCM__P5 TERM_VCM__P9 177.495
RNR289 TERM_VCM__P5 TERM_VCM__P10 189.035
RNR290 TERM_VCM__P5 TERM_VCM__P11 199.771
RNR291 TERM_VCM__P5 TERM_VCM__P12 210.368
RNR292 TERM_VCM__P5 TERM_VCM__P13 221.187
RNR293 TERM_VCM__P5 TERM_VCM__P14 232.654
RNR294 TERM_VCM__P5 TERM_VCM__P15 243.913
RNR295 TERM_VCM__P5 TERM_VCM__P16 255.741
RNR296 TERM_VCM__P5 TERM_VCM__P17 267.215
RNR297 TERM_VCM__P5 TERM_VCM__P18 278.667
RNR298 TERM_VCM__P5 TERM_VCM__P19 290.431
RNR299 TERM_VCM__P5 TERM_VCM__P20 301.552
RNR300 TERM_VCM__P5 TERM_VCM__P21 312.287
RNR301 TERM_VCM__P5 TERM_VCM__P22 322.864
RNR302 TERM_VCM__P5 TERM_VCM__P23 332.25
RNR303 TERM_VCM__P5 TERM_VCM__P24 340.386
RNR304 TERM_VCM__P5 TERM_VCM__N0 2629.51
RNR305 TERM_VCM__P5 TERM_VCM__N1 2676.17
RNR306 TERM_VCM__P5 TERM_VCM__N2 2694.36
RNR307 TERM_VCM__P5 TERM_VCM__N3 2691.64
RNR308 TERM_VCM__P5 TERM_VCM__N4 2674.17
RNR309 TERM_VCM__P5 TERM_VCM__N5 2642.94
RNR310 TERM_VCM__P5 TERM_VCM__N6 2602.42
RNR311 TERM_VCM__P5 TERM_VCM__N7 2552.9
RNR312 TERM_VCM__P5 TERM_VCM__N8 2493.37
RNR313 TERM_VCM__P5 TERM_VCM__N9 2429.21
RNR314 TERM_VCM__P5 TERM_VCM__N10 2378.54
RNR315 TERM_VCM__P5 TERM_VCM__N11 2301.98
RNR316 TERM_VCM__P5 TERM_VCM__N12 2224.13
RNR317 TERM_VCM__P5 TERM_VCM__N13 2143.37
RNR318 TERM_VCM__P5 TERM_VCM__N14 2057.83
RNR319 TERM_VCM__P5 TERM_VCM__N15 1974.5
RNR320 TERM_VCM__P5 TERM_VCM__N16 1887.9
RNR321 TERM_VCM__P5 TERM_VCM__N17 1804.88
RNR322 TERM_VCM__P5 TERM_VCM__N18 1722.85
RNR323 TERM_VCM__P5 TERM_VCM__N19 1639.42
RNR324 TERM_VCM__P5 TERM_VCM__N20 1561.3
RNR325 TERM_VCM__P5 TERM_VCM__N21 1485.82
RNR326 TERM_VCM__P5 TERM_VCM__N22 1411.27
RNR327 TERM_VCM__P5 TERM_VCM__N23 1344.57
RNR328 TERM_VCM__P5 TERM_VCM__N24 1285.04
RNR329 TERM_VCM__P6 TERM_VCM__P7 152.244
RNR330 TERM_VCM__P6 TERM_VCM__P8 163.017
RNR331 TERM_VCM__P6 TERM_VCM__P9 173.05
RNR332 TERM_VCM__P6 TERM_VCM__P10 184.601
RNR333 TERM_VCM__P6 TERM_VCM__P11 195.227
RNR334 TERM_VCM__P6 TERM_VCM__P12 205.667
RNR335 TERM_VCM__P6 TERM_VCM__P13 216.292
RNR336 TERM_VCM__P6 TERM_VCM__P14 227.532
RNR337 TERM_VCM__P6 TERM_VCM__P15 238.561
RNR338 TERM_VCM__P6 TERM_VCM__P16 250.139
RNR339 TERM_VCM__P6 TERM_VCM__P17 261.368
RNR340 TERM_VCM__P6 TERM_VCM__P18 272.574
RNR341 TERM_VCM__P6 TERM_VCM__P19 284.084
RNR342 TERM_VCM__P6 TERM_VCM__P20 294.965
RNR343 TERM_VCM__P6 TERM_VCM__P21 305.468
RNR344 TERM_VCM__P6 TERM_VCM__P22 315.817
RNR345 TERM_VCM__P6 TERM_VCM__P23 325
RNR346 TERM_VCM__P6 TERM_VCM__P24 332.961
RNR347 TERM_VCM__P6 TERM_VCM__N0 2602.21
RNR348 TERM_VCM__P6 TERM_VCM__N1 2643.82
RNR349 TERM_VCM__P6 TERM_VCM__N2 2658.71
RNR350 TERM_VCM__P6 TERM_VCM__N3 2653.74
RNR351 TERM_VCM__P6 TERM_VCM__N4 2634.74
RNR352 TERM_VCM__P6 TERM_VCM__N5 2602.42
RNR353 TERM_VCM__P6 TERM_VCM__N6 2561.2
RNR354 TERM_VCM__P6 TERM_VCM__N7 2511.28
RNR355 TERM_VCM__P6 TERM_VCM__N8 2451.59
RNR356 TERM_VCM__P6 TERM_VCM__N9 2387.52
RNR357 TERM_VCM__P6 TERM_VCM__N10 2336.83
RNR358 TERM_VCM__P6 TERM_VCM__N11 2260.76
RNR359 TERM_VCM__P6 TERM_VCM__N12 2183.56
RNR360 TERM_VCM__P6 TERM_VCM__N13 2103.63
RNR361 TERM_VCM__P6 TERM_VCM__N14 2019.07
RNR362 TERM_VCM__P6 TERM_VCM__N15 1936.79
RNR363 TERM_VCM__P6 TERM_VCM__N16 1851.38
RNR364 TERM_VCM__P6 TERM_VCM__N17 1769.57
RNR365 TERM_VCM__P6 TERM_VCM__N18 1688.8
RNR366 TERM_VCM__P6 TERM_VCM__N19 1606.72
RNR367 TERM_VCM__P6 TERM_VCM__N20 1529.9
RNR368 TERM_VCM__P6 TERM_VCM__N21 1455.72
RNR369 TERM_VCM__P6 TERM_VCM__N22 1382.49
RNR370 TERM_VCM__P6 TERM_VCM__N23 1317
RNR371 TERM_VCM__P6 TERM_VCM__N24 1258.58
RNR372 TERM_VCM__P7 TERM_VCM__P8 156.991
RNR373 TERM_VCM__P7 TERM_VCM__P9 167.681
RNR374 TERM_VCM__P7 TERM_VCM__P10 179.431
RNR375 TERM_VCM__P7 TERM_VCM__P11 190.032
RNR376 TERM_VCM__P7 TERM_VCM__P12 200.349
RNR377 TERM_VCM__P7 TERM_VCM__P13 210.787
RNR378 TERM_VCM__P7 TERM_VCM__P14 221.79
RNR379 TERM_VCM__P7 TERM_VCM__P15 232.57
RNR380 TERM_VCM__P7 TERM_VCM__P16 243.874
RNR381 TERM_VCM__P7 TERM_VCM__P17 254.833
RNR382 TERM_VCM__P7 TERM_VCM__P18 265.766
RNR383 TERM_VCM__P7 TERM_VCM__P19 276.993
RNR384 TERM_VCM__P7 TERM_VCM__P20 287.606
RNR385 TERM_VCM__P7 TERM_VCM__P21 297.85
RNR386 TERM_VCM__P7 TERM_VCM__P22 307.943
RNR387 TERM_VCM__P7 TERM_VCM__P23 316.899
RNR388 TERM_VCM__P7 TERM_VCM__P24 324.663
RNR389 TERM_VCM__P7 TERM_VCM__N0 2564.52
RNR390 TERM_VCM__P7 TERM_VCM__N1 2601.37
RNR391 TERM_VCM__P7 TERM_VCM__N2 2613.23
RNR392 TERM_VCM__P7 TERM_VCM__N3 2606.29
RNR393 TERM_VCM__P7 TERM_VCM__N4 2586.01
RNR394 TERM_VCM__P7 TERM_VCM__N5 2552.9
RNR395 TERM_VCM__P7 TERM_VCM__N6 2511.28
RNR396 TERM_VCM__P7 TERM_VCM__N7 2461.26
RNR397 TERM_VCM__P7 TERM_VCM__N8 2401.76
RNR398 TERM_VCM__P7 TERM_VCM__N9 2338.11
RNR399 TERM_VCM__P7 TERM_VCM__N10 2287.65
RNR400 TERM_VCM__P7 TERM_VCM__N11 2212.43
RNR401 TERM_VCM__P7 TERM_VCM__N12 2136.23
RNR402 TERM_VCM__P7 TERM_VCM__N13 2057.44
RNR403 TERM_VCM__P7 TERM_VCM__N14 1974.2
RNR404 TERM_VCM__P7 TERM_VCM__N15 1893.29
RNR405 TERM_VCM__P7 TERM_VCM__N16 1809.38
RNR406 TERM_VCM__P7 TERM_VCM__N17 1729.08
RNR407 TERM_VCM__P7 TERM_VCM__N18 1649.85
RNR408 TERM_VCM__P7 TERM_VCM__N19 1569.39
RNR409 TERM_VCM__P7 TERM_VCM__N20 1494.13
RNR410 TERM_VCM__P7 TERM_VCM__N21 1421.5
RNR411 TERM_VCM__P7 TERM_VCM__N22 1349.82
RNR412 TERM_VCM__P7 TERM_VCM__N23 1285.74
RNR413 TERM_VCM__P7 TERM_VCM__N24 1228.6
RNR414 TERM_VCM__P8 TERM_VCM__P9 160.779
RNR415 TERM_VCM__P8 TERM_VCM__P10 173.195
RNR416 TERM_VCM__P8 TERM_VCM__P11 183.939
RNR417 TERM_VCM__P8 TERM_VCM__P12 194.212
RNR418 TERM_VCM__P8 TERM_VCM__P13 204.49
RNR419 TERM_VCM__P8 TERM_VCM__P14 215.253
RNR420 TERM_VCM__P8 TERM_VCM__P15 225.766
RNR421 TERM_VCM__P8 TERM_VCM__P16 236.769
RNR422 TERM_VCM__P8 TERM_VCM__P17 247.427
RNR423 TERM_VCM__P8 TERM_VCM__P18 258.053
RNR424 TERM_VCM__P8 TERM_VCM__P19 268.961
RNR425 TERM_VCM__P8 TERM_VCM__P20 279.271
RNR426 TERM_VCM__P8 TERM_VCM__P21 289.221
RNR427 TERM_VCM__P8 TERM_VCM__P22 299.025
RNR428 TERM_VCM__P8 TERM_VCM__P23 307.724
RNR429 TERM_VCM__P8 TERM_VCM__P24 315.265
RNR430 TERM_VCM__P8 TERM_VCM__N0 2515.96
RNR431 TERM_VCM__P8 TERM_VCM__N1 2548.15
RNR432 TERM_VCM__P8 TERM_VCM__N2 2557.12
RNR433 TERM_VCM__P8 TERM_VCM__N3 2548.38
RNR434 TERM_VCM__P8 TERM_VCM__N4 2527.03
RNR435 TERM_VCM__P8 TERM_VCM__N5 2493.36
RNR436 TERM_VCM__P8 TERM_VCM__N6 2451.59
RNR437 TERM_VCM__P8 TERM_VCM__N7 2401.76
RNR438 TERM_VCM__P8 TERM_VCM__N8 2342.76
RNR439 TERM_VCM__P8 TERM_VCM__N9 2279.85
RNR440 TERM_VCM__P8 TERM_VCM__N10 2229.89
RNR441 TERM_VCM__P8 TERM_VCM__N11 2155.86
RNR442 TERM_VCM__P8 TERM_VCM__N12 2080.99
RNR443 TERM_VCM__P8 TERM_VCM__N13 2003.69
RNR444 TERM_VCM__P8 TERM_VCM__N14 1922.12
RNR445 TERM_VCM__P8 TERM_VCM__N15 1842.92
RNR446 TERM_VCM__P8 TERM_VCM__N16 1760.85
RNR447 TERM_VCM__P8 TERM_VCM__N17 1682.38
RNR448 TERM_VCM__P8 TERM_VCM__N18 1605.01
RNR449 TERM_VCM__P8 TERM_VCM__N19 1526.48
RNR450 TERM_VCM__P8 TERM_VCM__N20 1453.07
RNR451 TERM_VCM__P8 TERM_VCM__N21 1382.25
RNR452 TERM_VCM__P8 TERM_VCM__N22 1312.4
RNR453 TERM_VCM__P8 TERM_VCM__N23 1249.97
RNR454 TERM_VCM__P8 TERM_VCM__N24 1194.32
RNR455 TERM_VCM__P9 TERM_VCM__P10 165.917
RNR456 TERM_VCM__P9 TERM_VCM__P11 177.183
RNR457 TERM_VCM__P9 TERM_VCM__P12 187.619
RNR458 TERM_VCM__P9 TERM_VCM__P13 197.847
RNR459 TERM_VCM__P9 TERM_VCM__P14 208.424
RNR460 TERM_VCM__P9 TERM_VCM__P15 218.697
RNR461 TERM_VCM__P9 TERM_VCM__P16 229.408
RNR462 TERM_VCM__P9 TERM_VCM__P17 239.766
RNR463 TERM_VCM__P9 TERM_VCM__P18 250.081
RNR464 TERM_VCM__P9 TERM_VCM__P19 260.664
RNR465 TERM_VCM__P9 TERM_VCM__P20 270.663
RNR466 TERM_VCM__P9 TERM_VCM__P21 280.311
RNR467 TERM_VCM__P9 TERM_VCM__P22 289.815
RNR468 TERM_VCM__P9 TERM_VCM__P23 298.249
RNR469 TERM_VCM__P9 TERM_VCM__P24 305.559
RNR470 TERM_VCM__P9 TERM_VCM__N0 2461.21
RNR471 TERM_VCM__P9 TERM_VCM__N1 2489.18
RNR472 TERM_VCM__P9 TERM_VCM__N2 2495.59
RNR473 TERM_VCM__P9 TERM_VCM__N3 2485.33
RNR474 TERM_VCM__P9 TERM_VCM__N4 2463.17
RNR475 TERM_VCM__P9 TERM_VCM__N5 2429.2
RNR476 TERM_VCM__P9 TERM_VCM__N6 2387.52
RNR477 TERM_VCM__P9 TERM_VCM__N7 2338.11
RNR478 TERM_VCM__P9 TERM_VCM__N8 2279.85
RNR479 TERM_VCM__P9 TERM_VCM__N9 2217.9
RNR480 TERM_VCM__P9 TERM_VCM__N10 2168.63
RNR481 TERM_VCM__P9 TERM_VCM__N11 2096.01
RNR482 TERM_VCM__P9 TERM_VCM__N12 2022.69
RNR483 TERM_VCM__P9 TERM_VCM__N13 1947.08
RNR484 TERM_VCM__P9 TERM_VCM__N14 1867.37
RNR485 TERM_VCM__P9 TERM_VCM__N15 1790.05
RNR486 TERM_VCM__P9 TERM_VCM__N16 1710
RNR487 TERM_VCM__P9 TERM_VCM__N17 1633.51
RNR488 TERM_VCM__P9 TERM_VCM__N18 1558.14
RNR489 TERM_VCM__P9 TERM_VCM__N19 1481.69
RNR490 TERM_VCM__P9 TERM_VCM__N20 1410.25
RNR491 TERM_VCM__P9 TERM_VCM__N21 1341.36
RNR492 TERM_VCM__P9 TERM_VCM__N22 1273.44
RNR493 TERM_VCM__P9 TERM_VCM__N23 1212.76
RNR494 TERM_VCM__P9 TERM_VCM__N24 1158.68
RNR495 TERM_VCM__P10 TERM_VCM__P11 169.324
RNR496 TERM_VCM__P10 TERM_VCM__P12 181.185
RNR497 TERM_VCM__P10 TERM_VCM__P13 191.982
RNR498 TERM_VCM__P10 TERM_VCM__P14 202.7
RNR499 TERM_VCM__P10 TERM_VCM__P15 212.909
RNR500 TERM_VCM__P10 TERM_VCM__P16 223.445
RNR501 TERM_VCM__P10 TERM_VCM__P17 233.589
RNR502 TERM_VCM__P10 TERM_VCM__P18 243.666
RNR503 TERM_VCM__P10 TERM_VCM__P19 253.992
RNR504 TERM_VCM__P10 TERM_VCM__P20 263.744
RNR505 TERM_VCM__P10 TERM_VCM__P21 273.15
RNR506 TERM_VCM__P10 TERM_VCM__P22 282.416
RNR507 TERM_VCM__P10 TERM_VCM__P23 290.636
RNR508 TERM_VCM__P10 TERM_VCM__P24 297.762
RNR509 TERM_VCM__P10 TERM_VCM__N0 2419.34
RNR510 TERM_VCM__P10 TERM_VCM__N1 2443.57
RNR511 TERM_VCM__P10 TERM_VCM__N2 2447.7
RNR512 TERM_VCM__P10 TERM_VCM__N3 2436.04
RNR513 TERM_VCM__P10 TERM_VCM__N4 2413.09
RNR514 TERM_VCM__P10 TERM_VCM__N5 2378.74
RNR515 TERM_VCM__P10 TERM_VCM__N6 2337.02
RNR516 TERM_VCM__P10 TERM_VCM__N7 2287.85
RNR517 TERM_VCM__P10 TERM_VCM__N8 2230.08
RNR518 TERM_VCM__P10 TERM_VCM__N9 2168.82
RNR519 TERM_VCM__P10 TERM_VCM__N10 2120.03
RNR520 TERM_VCM__P10 TERM_VCM__N11 2048.48
RNR521 TERM_VCM__P10 TERM_VCM__N12 1976.33
RNR522 TERM_VCM__P10 TERM_VCM__N13 1902.01
RNR523 TERM_VCM__P10 TERM_VCM__N14 1823.75
RNR524 TERM_VCM__P10 TERM_VCM__N15 1747.89
RNR525 TERM_VCM__P10 TERM_VCM__N16 1669.42
RNR526 TERM_VCM__P10 TERM_VCM__N17 1594.48
RNR527 TERM_VCM__P10 TERM_VCM__N18 1520.69
RNR528 TERM_VCM__P10 TERM_VCM__N19 1445.87
RNR529 TERM_VCM__P10 TERM_VCM__N20 1376
RNR530 TERM_VCM__P10 TERM_VCM__N21 1308.64
RNR531 TERM_VCM__P10 TERM_VCM__N22 1242.26
RNR532 TERM_VCM__P10 TERM_VCM__N23 1182.96
RNR533 TERM_VCM__P10 TERM_VCM__N24 1130.13
RNR534 TERM_VCM__P11 TERM_VCM__P12 171.54
RNR535 TERM_VCM__P11 TERM_VCM__P13 183.402
RNR536 TERM_VCM__P11 TERM_VCM__P14 194.473
RNR537 TERM_VCM__P11 TERM_VCM__P15 204.681
RNR538 TERM_VCM__P11 TERM_VCM__P16 215.022
RNR539 TERM_VCM__P11 TERM_VCM__P17 224.894
RNR540 TERM_VCM__P11 TERM_VCM__P18 234.655
RNR541 TERM_VCM__P11 TERM_VCM__P19 244.63
RNR542 TERM_VCM__P11 TERM_VCM__P20 254.04
RNR543 TERM_VCM__P11 TERM_VCM__P21 263.111
RNR544 TERM_VCM__P11 TERM_VCM__P22 272.041
RNR545 TERM_VCM__P11 TERM_VCM__P23 279.964
RNR546 TERM_VCM__P11 TERM_VCM__P24 286.829
RNR547 TERM_VCM__P11 TERM_VCM__N0 2350.19
RNR548 TERM_VCM__P11 TERM_VCM__N1 2370.65
RNR549 TERM_VCM__P11 TERM_VCM__N2 2372.61
RNR550 TERM_VCM__P11 TERM_VCM__N3 2359.81
RNR551 TERM_VCM__P11 TERM_VCM__N4 2336.42
RNR552 TERM_VCM__P11 TERM_VCM__N5 2302.17
RNR553 TERM_VCM__P11 TERM_VCM__N6 2260.95
RNR554 TERM_VCM__P11 TERM_VCM__N7 2212.62
RNR555 TERM_VCM__P11 TERM_VCM__N8 2156.04
RNR556 TERM_VCM__P11 TERM_VCM__N9 2096.19
RNR557 TERM_VCM__P11 TERM_VCM__N10 2048.47
RNR558 TERM_VCM__P11 TERM_VCM__N11 1978.81
RNR559 TERM_VCM__P11 TERM_VCM__N12 1908.66
RNR560 TERM_VCM__P11 TERM_VCM__N13 1836.48
RNR561 TERM_VCM__P11 TERM_VCM__N14 1760.54
RNR562 TERM_VCM__P11 TERM_VCM__N15 1687
RNR563 TERM_VCM__P11 TERM_VCM__N16 1610.97
RNR564 TERM_VCM__P11 TERM_VCM__N17 1538.42
RNR565 TERM_VCM__P11 TERM_VCM__N18 1467.02
RNR566 TERM_VCM__P11 TERM_VCM__N19 1394.65
RNR567 TERM_VCM__P11 TERM_VCM__N20 1327.1
RNR568 TERM_VCM__P11 TERM_VCM__N21 1262.01
RNR569 TERM_VCM__P11 TERM_VCM__N22 1197.87
RNR570 TERM_VCM__P11 TERM_VCM__N23 1140.6
RNR571 TERM_VCM__P11 TERM_VCM__N24 1089.59
RNR572 TERM_VCM__P12 TERM_VCM__P13 173.417
RNR573 TERM_VCM__P12 TERM_VCM__P14 185.563
RNR574 TERM_VCM__P12 TERM_VCM__P15 196.131
RNR575 TERM_VCM__P12 TERM_VCM__P16 206.462
RNR576 TERM_VCM__P12 TERM_VCM__P17 216.156
RNR577 TERM_VCM__P12 TERM_VCM__P18 225.649
RNR578 TERM_VCM__P12 TERM_VCM__P19 235.3
RNR579 TERM_VCM__P12 TERM_VCM__P20 244.384
RNR580 TERM_VCM__P12 TERM_VCM__P21 253.127
RNR581 TERM_VCM__P12 TERM_VCM__P22 261.729
RNR582 TERM_VCM__P12 TERM_VCM__P23 269.356
RNR583 TERM_VCM__P12 TERM_VCM__P24 275.962
RNR584 TERM_VCM__P12 TERM_VCM__N0 2278.35
RNR585 TERM_VCM__P12 TERM_VCM__N1 2295.48
RNR586 TERM_VCM__P12 TERM_VCM__N2 2295.59
RNR587 TERM_VCM__P12 TERM_VCM__N3 2281.91
RNR588 TERM_VCM__P12 TERM_VCM__N4 2258.28
RNR589 TERM_VCM__P12 TERM_VCM__N5 2224.31
RNR590 TERM_VCM__P12 TERM_VCM__N6 2183.75
RNR591 TERM_VCM__P12 TERM_VCM__N7 2136.41
RNR592 TERM_VCM__P12 TERM_VCM__N8 2081.17
RNR593 TERM_VCM__P12 TERM_VCM__N9 2022.86
RNR594 TERM_VCM__P12 TERM_VCM__N10 1976.33
RNR595 TERM_VCM__P12 TERM_VCM__N11 1908.66
RNR596 TERM_VCM__P12 TERM_VCM__N12 1840.6
RNR597 TERM_VCM__P12 TERM_VCM__N13 1770.64
RNR598 TERM_VCM__P12 TERM_VCM__N14 1697.11
RNR599 TERM_VCM__P12 TERM_VCM__N15 1625.94
RNR600 TERM_VCM__P12 TERM_VCM__N16 1552.42
RNR601 TERM_VCM__P12 TERM_VCM__N17 1482.3
RNR602 TERM_VCM__P12 TERM_VCM__N18 1413.32
RNR603 TERM_VCM__P12 TERM_VCM__N19 1343.45
RNR604 TERM_VCM__P12 TERM_VCM__N20 1278.24
RNR605 TERM_VCM__P12 TERM_VCM__N21 1215.43
RNR606 TERM_VCM__P12 TERM_VCM__N22 1153.57
RNR607 TERM_VCM__P12 TERM_VCM__N23 1098.34
RNR608 TERM_VCM__P12 TERM_VCM__N24 1049.15
RNR609 TERM_VCM__P13 TERM_VCM__P14 175.098
RNR610 TERM_VCM__P13 TERM_VCM__P15 186.722
RNR611 TERM_VCM__P13 TERM_VCM__P16 197.395
RNR612 TERM_VCM__P13 TERM_VCM__P17 207.083
RNR613 TERM_VCM__P13 TERM_VCM__P18 216.391
RNR614 TERM_VCM__P13 TERM_VCM__P19 225.758
RNR615 TERM_VCM__P13 TERM_VCM__P20 234.531
RNR616 TERM_VCM__P13 TERM_VCM__P21 242.954
RNR617 TERM_VCM__P13 TERM_VCM__P22 251.226
RNR618 TERM_VCM__P13 TERM_VCM__P23 258.555
RNR619 TERM_VCM__P13 TERM_VCM__P24 264.899
RNR620 TERM_VCM__P13 TERM_VCM__N0 2202.52
RNR621 TERM_VCM__P13 TERM_VCM__N1 2216.64
RNR622 TERM_VCM__P13 TERM_VCM__N2 2215.14
RNR623 TERM_VCM__P13 TERM_VCM__N3 2200.77
RNR624 TERM_VCM__P13 TERM_VCM__N4 2177.07
RNR625 TERM_VCM__P13 TERM_VCM__N5 2143.55
RNR626 TERM_VCM__P13 TERM_VCM__N6 2103.81
RNR627 TERM_VCM__P13 TERM_VCM__N7 2057.62
RNR628 TERM_VCM__P13 TERM_VCM__N8 2003.86
RNR629 TERM_VCM__P13 TERM_VCM__N9 1947.25
RNR630 TERM_VCM__P13 TERM_VCM__N10 1902.01
RNR631 TERM_VCM__P13 TERM_VCM__N11 1836.48
RNR632 TERM_VCM__P13 TERM_VCM__N12 1770.64
RNR633 TERM_VCM__P13 TERM_VCM__N13 1703.04
RNR634 TERM_VCM__P13 TERM_VCM__N14 1632.02
RNR635 TERM_VCM__P13 TERM_VCM__N15 1563.34
RNR636 TERM_VCM__P13 TERM_VCM__N16 1492.43
RNR637 TERM_VCM__P13 TERM_VCM__N17 1424.84
RNR638 TERM_VCM__P13 TERM_VCM__N18 1358.37
RNR639 TERM_VCM__P13 TERM_VCM__N19 1291.07
RNR640 TERM_VCM__P13 TERM_VCM__N20 1228.29
RNR641 TERM_VCM__P13 TERM_VCM__N21 1167.84
RNR642 TERM_VCM__P13 TERM_VCM__N22 1108.31
RNR643 TERM_VCM__P13 TERM_VCM__N23 1055.18
RNR644 TERM_VCM__P13 TERM_VCM__N24 1007.87
RNR645 TERM_VCM__P14 TERM_VCM__P15 175.498
RNR646 TERM_VCM__P14 TERM_VCM__P16 187.246
RNR647 TERM_VCM__P14 TERM_VCM__P17 197.281
RNR648 TERM_VCM__P14 TERM_VCM__P18 206.569
RNR649 TERM_VCM__P14 TERM_VCM__P19 215.725
RNR650 TERM_VCM__P14 TERM_VCM__P20 224.218
RNR651 TERM_VCM__P14 TERM_VCM__P21 232.327
RNR652 TERM_VCM__P14 TERM_VCM__P22 240.266
RNR653 TERM_VCM__P14 TERM_VCM__P23 247.29
RNR654 TERM_VCM__P14 TERM_VCM__P24 253.361
RNR655 TERM_VCM__P14 TERM_VCM__N0 2121
RNR656 TERM_VCM__P14 TERM_VCM__N1 2132.34
RNR657 TERM_VCM__P14 TERM_VCM__N2 2129.41
RNR658 TERM_VCM__P14 TERM_VCM__N3 2114.51
RNR659 TERM_VCM__P14 TERM_VCM__N4 2090.92
RNR660 TERM_VCM__P14 TERM_VCM__N5 2058.01
RNR661 TERM_VCM__P14 TERM_VCM__N6 2019.24
RNR662 TERM_VCM__P14 TERM_VCM__N7 1974.37
RNR663 TERM_VCM__P14 TERM_VCM__N8 1922.29
RNR664 TERM_VCM__P14 TERM_VCM__N9 1867.54
RNR665 TERM_VCM__P14 TERM_VCM__N10 1823.75
RNR666 TERM_VCM__P14 TERM_VCM__N11 1760.54
RNR667 TERM_VCM__P14 TERM_VCM__N12 1697.11
RNR668 TERM_VCM__P14 TERM_VCM__N13 1632.02
RNR669 TERM_VCM__P14 TERM_VCM__N14 1563.71
RNR670 TERM_VCM__P14 TERM_VCM__N15 1497.68
RNR671 TERM_VCM__P14 TERM_VCM__N16 1429.55
RNR672 TERM_VCM__P14 TERM_VCM__N17 1364.64
RNR673 TERM_VCM__P14 TERM_VCM__N18 1300.83
RNR674 TERM_VCM__P14 TERM_VCM__N19 1236.26
RNR675 TERM_VCM__P14 TERM_VCM__N20 1176.03
RNR676 TERM_VCM__P14 TERM_VCM__N21 1118.06
RNR677 TERM_VCM__P14 TERM_VCM__N22 1060.99
RNR678 TERM_VCM__P14 TERM_VCM__N23 1010.06
RNR679 TERM_VCM__P14 TERM_VCM__N24 964.724
RNR680 TERM_VCM__P15 TERM_VCM__P16 176
RNR681 TERM_VCM__P15 TERM_VCM__P17 187.106
RNR682 TERM_VCM__P15 TERM_VCM__P18 196.749
RNR683 TERM_VCM__P15 TERM_VCM__P19 205.892
RNR684 TERM_VCM__P15 TERM_VCM__P20 214.209
RNR685 TERM_VCM__P15 TERM_VCM__P21 222.064
RNR686 TERM_VCM__P15 TERM_VCM__P22 229.707
RNR687 TERM_VCM__P15 TERM_VCM__P23 236.447
RNR688 TERM_VCM__P15 TERM_VCM__P24 242.257
RNR689 TERM_VCM__P15 TERM_VCM__N0 2040.57
RNR690 TERM_VCM__P15 TERM_VCM__N1 2049.55
RNR691 TERM_VCM__P15 TERM_VCM__N2 2045.46
RNR692 TERM_VCM__P15 TERM_VCM__N3 2030.23
RNR693 TERM_VCM__P15 TERM_VCM__N4 2006.86
RNR694 TERM_VCM__P15 TERM_VCM__N5 1974.67
RNR695 TERM_VCM__P15 TERM_VCM__N6 1936.95
RNR696 TERM_VCM__P15 TERM_VCM__N7 1893.45
RNR697 TERM_VCM__P15 TERM_VCM__N8 1843.08
RNR698 TERM_VCM__P15 TERM_VCM__N9 1790.21
RNR699 TERM_VCM__P15 TERM_VCM__N10 1747.9
RNR700 TERM_VCM__P15 TERM_VCM__N11 1687
RNR701 TERM_VCM__P15 TERM_VCM__N12 1625.95
RNR702 TERM_VCM__P15 TERM_VCM__N13 1563.34
RNR703 TERM_VCM__P15 TERM_VCM__N14 1497.68
RNR704 TERM_VCM__P15 TERM_VCM__N15 1434.26
RNR705 TERM_VCM__P15 TERM_VCM__N16 1368.84
RNR706 TERM_VCM__P15 TERM_VCM__N17 1306.54
RNR707 TERM_VCM__P15 TERM_VCM__N18 1245.33
RNR708 TERM_VCM__P15 TERM_VCM__N19 1183.4
RNR709 TERM_VCM__P15 TERM_VCM__N20 1125.66
RNR710 TERM_VCM__P15 TERM_VCM__N21 1070.1
RNR711 TERM_VCM__P15 TERM_VCM__N22 1015.4
RNR712 TERM_VCM__P15 TERM_VCM__N23 966.612
RNR713 TERM_VCM__P15 TERM_VCM__N24 923.183
RNR714 TERM_VCM__P16 TERM_VCM__P17 175.24
RNR715 TERM_VCM__P16 TERM_VCM__P18 185.962
RNR716 TERM_VCM__P16 TERM_VCM__P19 195.453
RNR717 TERM_VCM__P16 TERM_VCM__P20 203.761
RNR718 TERM_VCM__P16 TERM_VCM__P21 211.441
RNR719 TERM_VCM__P16 TERM_VCM__P22 218.819
RNR720 TERM_VCM__P16 TERM_VCM__P23 225.285
RNR721 TERM_VCM__P16 TERM_VCM__P24 230.832
RNR722 TERM_VCM__P16 TERM_VCM__N0 1956.07
RNR723 TERM_VCM__P16 TERM_VCM__N1 1962.9
RNR724 TERM_VCM__P16 TERM_VCM__N2 1957.83
RNR725 TERM_VCM__P16 TERM_VCM__N3 1942.41
RNR726 TERM_VCM__P16 TERM_VCM__N4 1919.4
RNR727 TERM_VCM__P16 TERM_VCM__N5 1888.06
RNR728 TERM_VCM__P16 TERM_VCM__N6 1851.54
RNR729 TERM_VCM__P16 TERM_VCM__N7 1809.54
RNR730 TERM_VCM__P16 TERM_VCM__N8 1761.01
RNR731 TERM_VCM__P16 TERM_VCM__N9 1710.15
RNR732 TERM_VCM__P16 TERM_VCM__N10 1669.43
RNR733 TERM_VCM__P16 TERM_VCM__N11 1610.98
RNR734 TERM_VCM__P16 TERM_VCM__N12 1552.43
RNR735 TERM_VCM__P16 TERM_VCM__N13 1492.44
RNR736 TERM_VCM__P16 TERM_VCM__N14 1429.55
RNR737 TERM_VCM__P16 TERM_VCM__N15 1368.84
RNR738 TERM_VCM__P16 TERM_VCM__N16 1306.26
RNR739 TERM_VCM__P16 TERM_VCM__N17 1246.68
RNR740 TERM_VCM__P16 TERM_VCM__N18 1188.16
RNR741 TERM_VCM__P16 TERM_VCM__N19 1128.97
RNR742 TERM_VCM__P16 TERM_VCM__N20 1073.81
RNR743 TERM_VCM__P16 TERM_VCM__N21 1020.73
RNR744 TERM_VCM__P16 TERM_VCM__N22 968.505
RNR745 TERM_VCM__P16 TERM_VCM__N23 921.917
RNR746 TERM_VCM__P16 TERM_VCM__N24 880.458
RNR747 TERM_VCM__P17 TERM_VCM__P18 174.247
RNR748 TERM_VCM__P17 TERM_VCM__P19 184.812
RNR749 TERM_VCM__P17 TERM_VCM__P20 193.476
RNR750 TERM_VCM__P17 TERM_VCM__P21 201.169
RNR751 TERM_VCM__P17 TERM_VCM__P22 208.383
RNR752 TERM_VCM__P17 TERM_VCM__P23 214.629
RNR753 TERM_VCM__P17 TERM_VCM__P24 219.935
RNR754 TERM_VCM__P17 TERM_VCM__N0 1874.28
RNR755 TERM_VCM__P17 TERM_VCM__N1 1879.33
RNR756 TERM_VCM__P17 TERM_VCM__N2 1873.49
RNR757 TERM_VCM__P17 TERM_VCM__N3 1858.02
RNR758 TERM_VCM__P17 TERM_VCM__N4 1835.47
RNR759 TERM_VCM__P17 TERM_VCM__N5 1805.04
RNR760 TERM_VCM__P17 TERM_VCM__N6 1769.72
RNR761 TERM_VCM__P17 TERM_VCM__N7 1729.23
RNR762 TERM_VCM__P17 TERM_VCM__N8 1682.53
RNR763 TERM_VCM__P17 TERM_VCM__N9 1633.66
RNR764 TERM_VCM__P17 TERM_VCM__N10 1594.49
RNR765 TERM_VCM__P17 TERM_VCM__N11 1538.43
RNR766 TERM_VCM__P17 TERM_VCM__N12 1482.31
RNR767 TERM_VCM__P17 TERM_VCM__N13 1424.84
RNR768 TERM_VCM__P17 TERM_VCM__N14 1364.64
RNR769 TERM_VCM__P17 TERM_VCM__N15 1306.54
RNR770 TERM_VCM__P17 TERM_VCM__N16 1246.68
RNR771 TERM_VCM__P17 TERM_VCM__N17 1189.71
RNR772 TERM_VCM__P17 TERM_VCM__N18 1133.77
RNR773 TERM_VCM__P17 TERM_VCM__N19 1077.21
RNR774 TERM_VCM__P17 TERM_VCM__N20 1024.51
RNR775 TERM_VCM__P17 TERM_VCM__N21 973.811
RNR776 TERM_VCM__P17 TERM_VCM__N22 923.932
RNR777 TERM_VCM__P17 TERM_VCM__N23 879.448
RNR778 TERM_VCM__P17 TERM_VCM__N24 839.866
RNR779 TERM_VCM__P18 TERM_VCM__P19 172.979
RNR780 TERM_VCM__P18 TERM_VCM__P20 182.691
RNR781 TERM_VCM__P18 TERM_VCM__P21 190.747
RNR782 TERM_VCM__P18 TERM_VCM__P22 197.968
RNR783 TERM_VCM__P18 TERM_VCM__P23 204.072
RNR784 TERM_VCM__P18 TERM_VCM__P24 209.162
RNR785 TERM_VCM__P18 TERM_VCM__N0 1792.78
RNR786 TERM_VCM__P18 TERM_VCM__N1 1796.31
RNR787 TERM_VCM__P18 TERM_VCM__N2 1789.87
RNR788 TERM_VCM__P18 TERM_VCM__N3 1774.48
RNR789 TERM_VCM__P18 TERM_VCM__N4 1752.47
RNR790 TERM_VCM__P18 TERM_VCM__N5 1723
RNR791 TERM_VCM__P18 TERM_VCM__N6 1688.95
RNR792 TERM_VCM__P18 TERM_VCM__N7 1650
RNR793 TERM_VCM__P18 TERM_VCM__N8 1605.16
RNR794 TERM_VCM__P18 TERM_VCM__N9 1558.28
RNR795 TERM_VCM__P18 TERM_VCM__N10 1520.7
RNR796 TERM_VCM__P18 TERM_VCM__N11 1467.02
RNR797 TERM_VCM__P18 TERM_VCM__N12 1413.33
RNR798 TERM_VCM__P18 TERM_VCM__N13 1358.38
RNR799 TERM_VCM__P18 TERM_VCM__N14 1300.84
RNR800 TERM_VCM__P18 TERM_VCM__N15 1245.34
RNR801 TERM_VCM__P18 TERM_VCM__N16 1188.17
RNR802 TERM_VCM__P18 TERM_VCM__N17 1133.78
RNR803 TERM_VCM__P18 TERM_VCM__N18 1080.39
RNR804 TERM_VCM__P18 TERM_VCM__N19 1026.42
RNR805 TERM_VCM__P18 TERM_VCM__N20 976.141
RNR806 TERM_VCM__P18 TERM_VCM__N21 927.788
RNR807 TERM_VCM__P18 TERM_VCM__N22 880.223
RNR808 TERM_VCM__P18 TERM_VCM__N23 837.809
RNR809 TERM_VCM__P18 TERM_VCM__N24 800.073
RNR810 TERM_VCM__P19 TERM_VCM__P20 170.445
RNR811 TERM_VCM__P19 TERM_VCM__P21 179.549
RNR812 TERM_VCM__P19 TERM_VCM__P22 187.109
RNR813 TERM_VCM__P19 TERM_VCM__P23 193.214
RNR814 TERM_VCM__P19 TERM_VCM__P24 198.13
RNR815 TERM_VCM__P19 TERM_VCM__N0 1709.29
RNR816 TERM_VCM__P19 TERM_VCM__N1 1711.47
RNR817 TERM_VCM__P19 TERM_VCM__N2 1704.58
RNR818 TERM_VCM__P19 TERM_VCM__N3 1689.36
RNR819 TERM_VCM__P19 TERM_VCM__N4 1667.98
RNR820 TERM_VCM__P19 TERM_VCM__N5 1639.57
RNR821 TERM_VCM__P19 TERM_VCM__N6 1606.86
RNR822 TERM_VCM__P19 TERM_VCM__N7 1569.53
RNR823 TERM_VCM__P19 TERM_VCM__N8 1526.62
RNR824 TERM_VCM__P19 TERM_VCM__N9 1481.82
RNR825 TERM_VCM__P19 TERM_VCM__N10 1445.89
RNR826 TERM_VCM__P19 TERM_VCM__N11 1394.66
RNR827 TERM_VCM__P19 TERM_VCM__N12 1343.46
RNR828 TERM_VCM__P19 TERM_VCM__N13 1291.08
RNR829 TERM_VCM__P19 TERM_VCM__N14 1236.26
RNR830 TERM_VCM__P19 TERM_VCM__N15 1183.41
RNR831 TERM_VCM__P19 TERM_VCM__N16 1128.98
RNR832 TERM_VCM__P19 TERM_VCM__N17 1077.21
RNR833 TERM_VCM__P19 TERM_VCM__N18 1026.42
RNR834 TERM_VCM__P19 TERM_VCM__N19 975.084
RNR835 TERM_VCM__P19 TERM_VCM__N20 927.267
RNR836 TERM_VCM__P19 TERM_VCM__N21 881.29
RNR837 TERM_VCM__P19 TERM_VCM__N22 836.07
RNR838 TERM_VCM__P19 TERM_VCM__N23 795.752
RNR839 TERM_VCM__P19 TERM_VCM__N24 759.886
RNR840 TERM_VCM__P20 TERM_VCM__P21 167.679
RNR841 TERM_VCM__P20 TERM_VCM__P22 176.244
RNR842 TERM_VCM__P20 TERM_VCM__P23 182.657
RNR843 TERM_VCM__P20 TERM_VCM__P24 187.507
RNR844 TERM_VCM__P20 TERM_VCM__N0 1630.59
RNR845 TERM_VCM__P20 TERM_VCM__N1 1631.69
RNR846 TERM_VCM__P20 TERM_VCM__N2 1624.48
RNR847 TERM_VCM__P20 TERM_VCM__N3 1609.52
RNR848 TERM_VCM__P20 TERM_VCM__N4 1588.8
RNR849 TERM_VCM__P20 TERM_VCM__N5 1561.44
RNR850 TERM_VCM__P20 TERM_VCM__N6 1530.04
RNR851 TERM_VCM__P20 TERM_VCM__N7 1494.27
RNR852 TERM_VCM__P20 TERM_VCM__N8 1453.21
RNR853 TERM_VCM__P20 TERM_VCM__N9 1410.38
RNR854 TERM_VCM__P20 TERM_VCM__N10 1376.01
RNR855 TERM_VCM__P20 TERM_VCM__N11 1327.11
RNR856 TERM_VCM__P20 TERM_VCM__N12 1278.25
RNR857 TERM_VCM__P20 TERM_VCM__N13 1228.3
RNR858 TERM_VCM__P20 TERM_VCM__N14 1176.04
RNR859 TERM_VCM__P20 TERM_VCM__N15 1125.67
RNR860 TERM_VCM__P20 TERM_VCM__N16 1073.81
RNR861 TERM_VCM__P20 TERM_VCM__N17 1024.51
RNR862 TERM_VCM__P20 TERM_VCM__N18 976.144
RNR863 TERM_VCM__P20 TERM_VCM__N19 927.268
RNR864 TERM_VCM__P20 TERM_VCM__N20 881.753
RNR865 TERM_VCM__P20 TERM_VCM__N21 837.996
RNR866 TERM_VCM__P20 TERM_VCM__N22 794.965
RNR867 TERM_VCM__P20 TERM_VCM__N23 756.604
RNR868 TERM_VCM__P20 TERM_VCM__N24 722.482
RNR869 TERM_VCM__P21 TERM_VCM__P22 164.393
RNR870 TERM_VCM__P21 TERM_VCM__P23 171.691
RNR871 TERM_VCM__P21 TERM_VCM__P24 176.677
RNR872 TERM_VCM__P21 TERM_VCM__N0 1554.12
RNR873 TERM_VCM__P21 TERM_VCM__N1 1554.34
RNR874 TERM_VCM__P21 TERM_VCM__N2 1546.92
RNR875 TERM_VCM__P21 TERM_VCM__N3 1532.28
RNR876 TERM_VCM__P21 TERM_VCM__N4 1512.26
RNR877 TERM_VCM__P21 TERM_VCM__N5 1485.96
RNR878 TERM_VCM__P21 TERM_VCM__N6 1455.86
RNR879 TERM_VCM__P21 TERM_VCM__N7 1421.63
RNR880 TERM_VCM__P21 TERM_VCM__N8 1382.39
RNR881 TERM_VCM__P21 TERM_VCM__N9 1341.49
RNR882 TERM_VCM__P21 TERM_VCM__N10 1308.66
RNR883 TERM_VCM__P21 TERM_VCM__N11 1262.02
RNR884 TERM_VCM__P21 TERM_VCM__N12 1215.45
RNR885 TERM_VCM__P21 TERM_VCM__N13 1167.85
RNR886 TERM_VCM__P21 TERM_VCM__N14 1118.07
RNR887 TERM_VCM__P21 TERM_VCM__N15 1070.1
RNR888 TERM_VCM__P21 TERM_VCM__N16 1020.74
RNR889 TERM_VCM__P21 TERM_VCM__N17 973.817
RNR890 TERM_VCM__P21 TERM_VCM__N18 927.793
RNR891 TERM_VCM__P21 TERM_VCM__N19 881.293
RNR892 TERM_VCM__P21 TERM_VCM__N20 837.998
RNR893 TERM_VCM__P21 TERM_VCM__N21 796.381
RNR894 TERM_VCM__P21 TERM_VCM__N22 755.46
RNR895 TERM_VCM__P21 TERM_VCM__N23 718.983
RNR896 TERM_VCM__P21 TERM_VCM__N24 686.54
RNR897 TERM_VCM__P22 TERM_VCM__P23 159.378
RNR898 TERM_VCM__P22 TERM_VCM__P24 164.938
RNR899 TERM_VCM__P22 TERM_VCM__N0 1478.23
RNR900 TERM_VCM__P22 TERM_VCM__N1 1477.69
RNR901 TERM_VCM__P22 TERM_VCM__N2 1470.17
RNR902 TERM_VCM__P22 TERM_VCM__N3 1455.91
RNR903 TERM_VCM__P22 TERM_VCM__N4 1436.61
RNR904 TERM_VCM__P22 TERM_VCM__N5 1411.41
RNR905 TERM_VCM__P22 TERM_VCM__N6 1382.63
RNR906 TERM_VCM__P22 TERM_VCM__N7 1349.96
RNR907 TERM_VCM__P22 TERM_VCM__N8 1312.53
RNR908 TERM_VCM__P22 TERM_VCM__N9 1273.57
RNR909 TERM_VCM__P22 TERM_VCM__N10 1242.27
RNR910 TERM_VCM__P22 TERM_VCM__N11 1197.89
RNR911 TERM_VCM__P22 TERM_VCM__N12 1153.58
RNR912 TERM_VCM__P22 TERM_VCM__N13 1108.32
RNR913 TERM_VCM__P22 TERM_VCM__N14 1061
RNR914 TERM_VCM__P22 TERM_VCM__N15 1015.42
RNR915 TERM_VCM__P22 TERM_VCM__N16 968.515
RNR916 TERM_VCM__P22 TERM_VCM__N17 923.94
RNR917 TERM_VCM__P22 TERM_VCM__N18 880.23
RNR918 TERM_VCM__P22 TERM_VCM__N19 836.075
RNR919 TERM_VCM__P22 TERM_VCM__N20 794.969
RNR920 TERM_VCM__P22 TERM_VCM__N21 755.461
RNR921 TERM_VCM__P22 TERM_VCM__N22 716.619
RNR922 TERM_VCM__P22 TERM_VCM__N23 681.998
RNR923 TERM_VCM__P22 TERM_VCM__N24 651.209
RNR924 TERM_VCM__P23 TERM_VCM__P24 152.155
RNR925 TERM_VCM__P23 TERM_VCM__N0 1410.02
RNR926 TERM_VCM__P23 TERM_VCM__N1 1408.92
RNR927 TERM_VCM__P23 TERM_VCM__N2 1401.36
RNR928 TERM_VCM__P23 TERM_VCM__N3 1387.5
RNR929 TERM_VCM__P23 TERM_VCM__N4 1368.9
RNR930 TERM_VCM__P23 TERM_VCM__N5 1344.7
RNR931 TERM_VCM__P23 TERM_VCM__N6 1317.13
RNR932 TERM_VCM__P23 TERM_VCM__N7 1285.87
RNR933 TERM_VCM__P23 TERM_VCM__N8 1250.1
RNR934 TERM_VCM__P23 TERM_VCM__N9 1212.88
RNR935 TERM_VCM__P23 TERM_VCM__N10 1182.98
RNR936 TERM_VCM__P23 TERM_VCM__N11 1140.62
RNR937 TERM_VCM__P23 TERM_VCM__N12 1098.35
RNR938 TERM_VCM__P23 TERM_VCM__N13 1055.19
RNR939 TERM_VCM__P23 TERM_VCM__N14 1010.07
RNR940 TERM_VCM__P23 TERM_VCM__N15 966.624
RNR941 TERM_VCM__P23 TERM_VCM__N16 921.928
RNR942 TERM_VCM__P23 TERM_VCM__N17 879.458
RNR943 TERM_VCM__P23 TERM_VCM__N18 837.816
RNR944 TERM_VCM__P23 TERM_VCM__N19 795.758
RNR945 TERM_VCM__P23 TERM_VCM__N20 756.609
RNR946 TERM_VCM__P23 TERM_VCM__N21 718.986
RNR947 TERM_VCM__P23 TERM_VCM__N22 682
RNR948 TERM_VCM__P23 TERM_VCM__N23 649.037
RNR949 TERM_VCM__P23 TERM_VCM__N24 619.724
RNR950 TERM_VCM__P24 TERM_VCM__N0 1348.93
RNR951 TERM_VCM__P24 TERM_VCM__N1 1347.41
RNR952 TERM_VCM__P24 TERM_VCM__N2 1339.88
RNR953 TERM_VCM__P24 TERM_VCM__N3 1326.4
RNR954 TERM_VCM__P24 TERM_VCM__N4 1308.45
RNR955 TERM_VCM__P24 TERM_VCM__N5 1285.18
RNR956 TERM_VCM__P24 TERM_VCM__N6 1258.7
RNR957 TERM_VCM__P24 TERM_VCM__N7 1228.72
RNR958 TERM_VCM__P24 TERM_VCM__N8 1194.44
RNR959 TERM_VCM__P24 TERM_VCM__N9 1158.8
RNR960 TERM_VCM__P24 TERM_VCM__N10 1130.15
RNR961 TERM_VCM__P24 TERM_VCM__N11 1089.61
RNR962 TERM_VCM__P24 TERM_VCM__N12 1049.17
RNR963 TERM_VCM__P24 TERM_VCM__N13 1007.88
RNR964 TERM_VCM__P24 TERM_VCM__N14 964.74
RNR965 TERM_VCM__P24 TERM_VCM__N15 923.197
RNR966 TERM_VCM__P24 TERM_VCM__N16 880.47
RNR967 TERM_VCM__P24 TERM_VCM__N17 839.877
RNR968 TERM_VCM__P24 TERM_VCM__N18 800.082
RNR969 TERM_VCM__P24 TERM_VCM__N19 759.893
RNR970 TERM_VCM__P24 TERM_VCM__N20 722.488
RNR971 TERM_VCM__P24 TERM_VCM__N21 686.544
RNR972 TERM_VCM__P24 TERM_VCM__N22 651.212
RNR973 TERM_VCM__P24 TERM_VCM__N23 619.725
RNR974 TERM_VCM__P24 TERM_VCM__N24 591.726
RNR975 TERM_VCM__N0 TERM_VCM__N1 116.309
RNR976 TERM_VCM__N0 TERM_VCM__N2 125.169
RNR977 TERM_VCM__N0 TERM_VCM__N3 133.897
RNR978 TERM_VCM__N0 TERM_VCM__N4 142.374
RNR979 TERM_VCM__N0 TERM_VCM__N5 151.339
RNR980 TERM_VCM__N0 TERM_VCM__N6 160.288
RNR981 TERM_VCM__N0 TERM_VCM__N7 169.552
RNR982 TERM_VCM__N0 TERM_VCM__N8 179.529
RNR983 TERM_VCM__N0 TERM_VCM__N9 189.513
RNR984 TERM_VCM__N0 TERM_VCM__N10 201.449
RNR985 TERM_VCM__N0 TERM_VCM__N11 212.727
RNR986 TERM_VCM__N0 TERM_VCM__N12 223.912
RNR987 TERM_VCM__N0 TERM_VCM__N13 235.366
RNR988 TERM_VCM__N0 TERM_VCM__N14 247.528
RNR989 TERM_VCM__N0 TERM_VCM__N15 259.479
RNR990 TERM_VCM__N0 TERM_VCM__N16 272.04
RNR991 TERM_VCM__N0 TERM_VCM__N17 284.226
RNR992 TERM_VCM__N0 TERM_VCM__N18 296.389
RNR993 TERM_VCM__N0 TERM_VCM__N19 308.882
RNR994 TERM_VCM__N0 TERM_VCM__N20 320.691
RNR995 TERM_VCM__N0 TERM_VCM__N21 332.086
RNR996 TERM_VCM__N0 TERM_VCM__N22 343.311
RNR997 TERM_VCM__N0 TERM_VCM__N23 353.267
RNR998 TERM_VCM__N0 TERM_VCM__N24 361.895
RNR999 TERM_VCM__N1 TERM_VCM__N2 123.673
RNR1000 TERM_VCM__N1 TERM_VCM__N3 132.714
RNR1001 TERM_VCM__N1 TERM_VCM__N4 141.309
RNR1002 TERM_VCM__N1 TERM_VCM__N5 150.308
RNR1003 TERM_VCM__N1 TERM_VCM__N6 159.256
RNR1004 TERM_VCM__N1 TERM_VCM__N7 168.496
RNR1005 TERM_VCM__N1 TERM_VCM__N8 178.431
RNR1006 TERM_VCM__N1 TERM_VCM__N9 188.368
RNR1007 TERM_VCM__N1 TERM_VCM__N10 200.242
RNR1008 TERM_VCM__N1 TERM_VCM__N11 211.458
RNR1009 TERM_VCM__N1 TERM_VCM__N12 222.581
RNR1010 TERM_VCM__N1 TERM_VCM__N13 233.97
RNR1011 TERM_VCM__N1 TERM_VCM__N14 246.065
RNR1012 TERM_VCM__N1 TERM_VCM__N15 257.949
RNR1013 TERM_VCM__N1 TERM_VCM__N16 270.44
RNR1014 TERM_VCM__N1 TERM_VCM__N17 282.559
RNR1015 TERM_VCM__N1 TERM_VCM__N18 294.656
RNR1016 TERM_VCM__N1 TERM_VCM__N19 307.083
RNR1017 TERM_VCM__N1 TERM_VCM__N20 318.83
RNR1018 TERM_VCM__N1 TERM_VCM__N21 330.166
RNR1019 TERM_VCM__N1 TERM_VCM__N22 341.335
RNR1020 TERM_VCM__N1 TERM_VCM__N23 351.243
RNR1021 TERM_VCM__N1 TERM_VCM__N24 359.829
RNR1022 TERM_VCM__N2 TERM_VCM__N3 130.344
RNR1023 TERM_VCM__N2 TERM_VCM__N4 139.431
RNR1024 TERM_VCM__N2 TERM_VCM__N5 148.627
RNR1025 TERM_VCM__N2 TERM_VCM__N6 157.651
RNR1026 TERM_VCM__N2 TERM_VCM__N7 166.898
RNR1027 TERM_VCM__N2 TERM_VCM__N8 176.799
RNR1028 TERM_VCM__N2 TERM_VCM__N9 186.681
RNR1029 TERM_VCM__N2 TERM_VCM__N10 198.476
RNR1030 TERM_VCM__N2 TERM_VCM__N11 209.605
RNR1031 TERM_VCM__N2 TERM_VCM__N12 220.637
RNR1032 TERM_VCM__N2 TERM_VCM__N13 231.933
RNR1033 TERM_VCM__N2 TERM_VCM__N14 243.926
RNR1034 TERM_VCM__N2 TERM_VCM__N15 255.711
RNR1035 TERM_VCM__N2 TERM_VCM__N16 268.097
RNR1036 TERM_VCM__N2 TERM_VCM__N17 280.115
RNR1037 TERM_VCM__N2 TERM_VCM__N18 292.111
RNR1038 TERM_VCM__N2 TERM_VCM__N19 304.434
RNR1039 TERM_VCM__N2 TERM_VCM__N20 316.084
RNR1040 TERM_VCM__N2 TERM_VCM__N21 327.328
RNR1041 TERM_VCM__N2 TERM_VCM__N22 338.406
RNR1042 TERM_VCM__N2 TERM_VCM__N23 348.234
RNR1043 TERM_VCM__N2 TERM_VCM__N24 356.753
RNR1044 TERM_VCM__N3 TERM_VCM__N4 136.262
RNR1045 TERM_VCM__N3 TERM_VCM__N5 146.021
RNR1046 TERM_VCM__N3 TERM_VCM__N6 155.268
RNR1047 TERM_VCM__N3 TERM_VCM__N7 164.584
RNR1048 TERM_VCM__N3 TERM_VCM__N8 174.467
RNR1049 TERM_VCM__N3 TERM_VCM__N9 184.291
RNR1050 TERM_VCM__N3 TERM_VCM__N10 195.987
RNR1051 TERM_VCM__N3 TERM_VCM__N11 206.998
RNR1052 TERM_VCM__N3 TERM_VCM__N12 217.907
RNR1053 TERM_VCM__N3 TERM_VCM__N13 229.072
RNR1054 TERM_VCM__N3 TERM_VCM__N14 240.923
RNR1055 TERM_VCM__N3 TERM_VCM__N15 252.567
RNR1056 TERM_VCM__N3 TERM_VCM__N16 264.804
RNR1057 TERM_VCM__N3 TERM_VCM__N17 276.677
RNR1058 TERM_VCM__N3 TERM_VCM__N18 288.529
RNR1059 TERM_VCM__N3 TERM_VCM__N19 300.704
RNR1060 TERM_VCM__N3 TERM_VCM__N20 312.215
RNR1061 TERM_VCM__N3 TERM_VCM__N21 323.324
RNR1062 TERM_VCM__N3 TERM_VCM__N22 334.27
RNR1063 TERM_VCM__N3 TERM_VCM__N23 343.983
RNR1064 TERM_VCM__N3 TERM_VCM__N24 352.401
RNR1065 TERM_VCM__N4 TERM_VCM__N5 142.187
RNR1066 TERM_VCM__N4 TERM_VCM__N6 152.037
RNR1067 TERM_VCM__N4 TERM_VCM__N7 161.579
RNR1068 TERM_VCM__N4 TERM_VCM__N8 171.513
RNR1069 TERM_VCM__N4 TERM_VCM__N9 181.305
RNR1070 TERM_VCM__N4 TERM_VCM__N10 192.907
RNR1071 TERM_VCM__N4 TERM_VCM__N11 203.786
RNR1072 TERM_VCM__N4 TERM_VCM__N12 214.551
RNR1073 TERM_VCM__N4 TERM_VCM__N13 225.559
RNR1074 TERM_VCM__N4 TERM_VCM__N14 237.238
RNR1075 TERM_VCM__N4 TERM_VCM__N15 248.71
RNR1076 TERM_VCM__N4 TERM_VCM__N16 260.764
RNR1077 TERM_VCM__N4 TERM_VCM__N17 272.46
RNR1078 TERM_VCM__N4 TERM_VCM__N18 284.134
RNR1079 TERM_VCM__N4 TERM_VCM__N19 296.126
RNR1080 TERM_VCM__N4 TERM_VCM__N20 307.464
RNR1081 TERM_VCM__N4 TERM_VCM__N21 318.408
RNR1082 TERM_VCM__N4 TERM_VCM__N22 329.19
RNR1083 TERM_VCM__N4 TERM_VCM__N23 338.758
RNR1084 TERM_VCM__N4 TERM_VCM__N24 347.051
RNR1085 TERM_VCM__N5 TERM_VCM__N6 147.383
RNR1086 TERM_VCM__N5 TERM_VCM__N7 157.545
RNR1087 TERM_VCM__N5 TERM_VCM__N8 167.681
RNR1088 TERM_VCM__N5 TERM_VCM__N9 177.504
RNR1089 TERM_VCM__N5 TERM_VCM__N10 189.028
RNR1090 TERM_VCM__N5 TERM_VCM__N11 199.764
RNR1091 TERM_VCM__N5 TERM_VCM__N12 210.362
RNR1092 TERM_VCM__N5 TERM_VCM__N13 221.181
RNR1093 TERM_VCM__N5 TERM_VCM__N14 232.648
RNR1094 TERM_VCM__N5 TERM_VCM__N15 243.908
RNR1095 TERM_VCM__N5 TERM_VCM__N16 255.736
RNR1096 TERM_VCM__N5 TERM_VCM__N17 267.21
RNR1097 TERM_VCM__N5 TERM_VCM__N18 278.663
RNR1098 TERM_VCM__N5 TERM_VCM__N19 290.427
RNR1099 TERM_VCM__N5 TERM_VCM__N20 301.55
RNR1100 TERM_VCM__N5 TERM_VCM__N21 312.285
RNR1101 TERM_VCM__N5 TERM_VCM__N22 322.863
RNR1102 TERM_VCM__N5 TERM_VCM__N23 332.25
RNR1103 TERM_VCM__N5 TERM_VCM__N24 340.386
RNR1104 TERM_VCM__N6 TERM_VCM__N7 152.25
RNR1105 TERM_VCM__N6 TERM_VCM__N8 163.024
RNR1106 TERM_VCM__N6 TERM_VCM__N9 173.058
RNR1107 TERM_VCM__N6 TERM_VCM__N10 184.594
RNR1108 TERM_VCM__N6 TERM_VCM__N11 195.221
RNR1109 TERM_VCM__N6 TERM_VCM__N12 205.661
RNR1110 TERM_VCM__N6 TERM_VCM__N13 216.286
RNR1111 TERM_VCM__N6 TERM_VCM__N14 227.527
RNR1112 TERM_VCM__N6 TERM_VCM__N15 238.556
RNR1113 TERM_VCM__N6 TERM_VCM__N16 250.134
RNR1114 TERM_VCM__N6 TERM_VCM__N17 261.364
RNR1115 TERM_VCM__N6 TERM_VCM__N18 272.57
RNR1116 TERM_VCM__N6 TERM_VCM__N19 284.081
RNR1117 TERM_VCM__N6 TERM_VCM__N20 294.963
RNR1118 TERM_VCM__N6 TERM_VCM__N21 305.466
RNR1119 TERM_VCM__N6 TERM_VCM__N22 315.816
RNR1120 TERM_VCM__N6 TERM_VCM__N23 325
RNR1121 TERM_VCM__N6 TERM_VCM__N24 332.961
RNR1122 TERM_VCM__N7 TERM_VCM__N8 156.998
RNR1123 TERM_VCM__N7 TERM_VCM__N9 167.689
RNR1124 TERM_VCM__N7 TERM_VCM__N10 179.425
RNR1125 TERM_VCM__N7 TERM_VCM__N11 190.026
RNR1126 TERM_VCM__N7 TERM_VCM__N12 200.343
RNR1127 TERM_VCM__N7 TERM_VCM__N13 210.781
RNR1128 TERM_VCM__N7 TERM_VCM__N14 221.785
RNR1129 TERM_VCM__N7 TERM_VCM__N15 232.565
RNR1130 TERM_VCM__N7 TERM_VCM__N16 243.87
RNR1131 TERM_VCM__N7 TERM_VCM__N17 254.829
RNR1132 TERM_VCM__N7 TERM_VCM__N18 265.763
RNR1133 TERM_VCM__N7 TERM_VCM__N19 276.99
RNR1134 TERM_VCM__N7 TERM_VCM__N20 287.604
RNR1135 TERM_VCM__N7 TERM_VCM__N21 297.848
RNR1136 TERM_VCM__N7 TERM_VCM__N22 307.942
RNR1137 TERM_VCM__N7 TERM_VCM__N23 316.899
RNR1138 TERM_VCM__N7 TERM_VCM__N24 324.664
RNR1139 TERM_VCM__N8 TERM_VCM__N9 160.787
RNR1140 TERM_VCM__N8 TERM_VCM__N10 173.189
RNR1141 TERM_VCM__N8 TERM_VCM__N11 183.933
RNR1142 TERM_VCM__N8 TERM_VCM__N12 194.206
RNR1143 TERM_VCM__N8 TERM_VCM__N13 204.484
RNR1144 TERM_VCM__N8 TERM_VCM__N14 215.248
RNR1145 TERM_VCM__N8 TERM_VCM__N15 225.762
RNR1146 TERM_VCM__N8 TERM_VCM__N16 236.765
RNR1147 TERM_VCM__N8 TERM_VCM__N17 247.424
RNR1148 TERM_VCM__N8 TERM_VCM__N18 258.05
RNR1149 TERM_VCM__N8 TERM_VCM__N19 268.959
RNR1150 TERM_VCM__N8 TERM_VCM__N20 279.269
RNR1151 TERM_VCM__N8 TERM_VCM__N21 289.22
RNR1152 TERM_VCM__N8 TERM_VCM__N22 299.024
RNR1153 TERM_VCM__N8 TERM_VCM__N23 307.724
RNR1154 TERM_VCM__N8 TERM_VCM__N24 315.265
RNR1155 TERM_VCM__N9 TERM_VCM__N10 165.912
RNR1156 TERM_VCM__N9 TERM_VCM__N11 177.178
RNR1157 TERM_VCM__N9 TERM_VCM__N12 187.614
RNR1158 TERM_VCM__N9 TERM_VCM__N13 197.842
RNR1159 TERM_VCM__N9 TERM_VCM__N14 208.419
RNR1160 TERM_VCM__N9 TERM_VCM__N15 218.693
RNR1161 TERM_VCM__N9 TERM_VCM__N16 229.404
RNR1162 TERM_VCM__N9 TERM_VCM__N17 239.763
RNR1163 TERM_VCM__N9 TERM_VCM__N18 250.078
RNR1164 TERM_VCM__N9 TERM_VCM__N19 260.661
RNR1165 TERM_VCM__N9 TERM_VCM__N20 270.661
RNR1166 TERM_VCM__N9 TERM_VCM__N21 280.309
RNR1167 TERM_VCM__N9 TERM_VCM__N22 289.814
RNR1168 TERM_VCM__N9 TERM_VCM__N23 298.249
RNR1169 TERM_VCM__N9 TERM_VCM__N24 305.56
RNR1170 TERM_VCM__N10 TERM_VCM__N11 169.304
RNR1171 TERM_VCM__N10 TERM_VCM__N12 181.164
RNR1172 TERM_VCM__N10 TERM_VCM__N13 191.961
RNR1173 TERM_VCM__N10 TERM_VCM__N14 202.678
RNR1174 TERM_VCM__N10 TERM_VCM__N15 212.886
RNR1175 TERM_VCM__N10 TERM_VCM__N16 223.422
RNR1176 TERM_VCM__N10 TERM_VCM__N17 233.565
RNR1177 TERM_VCM__N10 TERM_VCM__N18 243.642
RNR1178 TERM_VCM__N10 TERM_VCM__N19 253.968
RNR1179 TERM_VCM__N10 TERM_VCM__N20 263.719
RNR1180 TERM_VCM__N10 TERM_VCM__N21 273.126
RNR1181 TERM_VCM__N10 TERM_VCM__N22 282.391
RNR1182 TERM_VCM__N10 TERM_VCM__N23 290.611
RNR1183 TERM_VCM__N10 TERM_VCM__N24 297.736
RNR1184 TERM_VCM__N11 TERM_VCM__N12 171.52
RNR1185 TERM_VCM__N11 TERM_VCM__N13 183.382
RNR1186 TERM_VCM__N11 TERM_VCM__N14 194.452
RNR1187 TERM_VCM__N11 TERM_VCM__N15 204.66
RNR1188 TERM_VCM__N11 TERM_VCM__N16 215
RNR1189 TERM_VCM__N11 TERM_VCM__N17 224.871
RNR1190 TERM_VCM__N11 TERM_VCM__N18 234.632
RNR1191 TERM_VCM__N11 TERM_VCM__N19 244.607
RNR1192 TERM_VCM__N11 TERM_VCM__N20 254.017
RNR1193 TERM_VCM__N11 TERM_VCM__N21 263.087
RNR1194 TERM_VCM__N11 TERM_VCM__N22 272.017
RNR1195 TERM_VCM__N11 TERM_VCM__N23 279.939
RNR1196 TERM_VCM__N11 TERM_VCM__N24 286.804
RNR1197 TERM_VCM__N12 TERM_VCM__N13 173.398
RNR1198 TERM_VCM__N12 TERM_VCM__N14 185.543
RNR1199 TERM_VCM__N12 TERM_VCM__N15 196.111
RNR1200 TERM_VCM__N12 TERM_VCM__N16 206.44
RNR1201 TERM_VCM__N12 TERM_VCM__N17 216.134
RNR1202 TERM_VCM__N12 TERM_VCM__N18 225.627
RNR1203 TERM_VCM__N12 TERM_VCM__N19 235.278
RNR1204 TERM_VCM__N12 TERM_VCM__N20 244.361
RNR1205 TERM_VCM__N12 TERM_VCM__N21 253.104
RNR1206 TERM_VCM__N12 TERM_VCM__N22 261.705
RNR1207 TERM_VCM__N12 TERM_VCM__N23 269.332
RNR1208 TERM_VCM__N12 TERM_VCM__N24 275.939
RNR1209 TERM_VCM__N13 TERM_VCM__N14 175.079
RNR1210 TERM_VCM__N13 TERM_VCM__N15 186.702
RNR1211 TERM_VCM__N13 TERM_VCM__N16 197.374
RNR1212 TERM_VCM__N13 TERM_VCM__N17 207.062
RNR1213 TERM_VCM__N13 TERM_VCM__N18 216.37
RNR1214 TERM_VCM__N13 TERM_VCM__N19 225.736
RNR1215 TERM_VCM__N13 TERM_VCM__N20 234.509
RNR1216 TERM_VCM__N13 TERM_VCM__N21 242.932
RNR1217 TERM_VCM__N13 TERM_VCM__N22 251.203
RNR1218 TERM_VCM__N13 TERM_VCM__N23 258.533
RNR1219 TERM_VCM__N13 TERM_VCM__N24 264.876
RNR1220 TERM_VCM__N14 TERM_VCM__N15 175.479
RNR1221 TERM_VCM__N14 TERM_VCM__N16 187.227
RNR1222 TERM_VCM__N14 TERM_VCM__N17 197.261
RNR1223 TERM_VCM__N14 TERM_VCM__N18 206.549
RNR1224 TERM_VCM__N14 TERM_VCM__N19 215.704
RNR1225 TERM_VCM__N14 TERM_VCM__N20 224.197
RNR1226 TERM_VCM__N14 TERM_VCM__N21 232.306
RNR1227 TERM_VCM__N14 TERM_VCM__N22 240.245
RNR1228 TERM_VCM__N14 TERM_VCM__N23 247.268
RNR1229 TERM_VCM__N14 TERM_VCM__N24 253.339
RNR1230 TERM_VCM__N15 TERM_VCM__N16 175.982
RNR1231 TERM_VCM__N15 TERM_VCM__N17 187.087
RNR1232 TERM_VCM__N15 TERM_VCM__N18 196.73
RNR1233 TERM_VCM__N15 TERM_VCM__N19 205.872
RNR1234 TERM_VCM__N15 TERM_VCM__N20 214.189
RNR1235 TERM_VCM__N15 TERM_VCM__N21 222.044
RNR1236 TERM_VCM__N15 TERM_VCM__N22 229.686
RNR1237 TERM_VCM__N15 TERM_VCM__N23 236.426
RNR1238 TERM_VCM__N15 TERM_VCM__N24 242.236
RNR1239 TERM_VCM__N16 TERM_VCM__N17 175.223
RNR1240 TERM_VCM__N16 TERM_VCM__N18 185.944
RNR1241 TERM_VCM__N16 TERM_VCM__N19 195.434
RNR1242 TERM_VCM__N16 TERM_VCM__N20 203.742
RNR1243 TERM_VCM__N16 TERM_VCM__N21 211.421
RNR1244 TERM_VCM__N16 TERM_VCM__N22 218.799
RNR1245 TERM_VCM__N16 TERM_VCM__N23 225.265
RNR1246 TERM_VCM__N16 TERM_VCM__N24 230.812
RNR1247 TERM_VCM__N17 TERM_VCM__N18 174.229
RNR1248 TERM_VCM__N17 TERM_VCM__N19 184.793
RNR1249 TERM_VCM__N17 TERM_VCM__N20 193.458
RNR1250 TERM_VCM__N17 TERM_VCM__N21 201.15
RNR1251 TERM_VCM__N17 TERM_VCM__N22 208.364
RNR1252 TERM_VCM__N17 TERM_VCM__N23 214.61
RNR1253 TERM_VCM__N17 TERM_VCM__N24 219.915
RNR1254 TERM_VCM__N18 TERM_VCM__N19 172.962
RNR1255 TERM_VCM__N18 TERM_VCM__N20 182.673
RNR1256 TERM_VCM__N18 TERM_VCM__N21 190.729
RNR1257 TERM_VCM__N18 TERM_VCM__N22 197.95
RNR1258 TERM_VCM__N18 TERM_VCM__N23 204.053
RNR1259 TERM_VCM__N18 TERM_VCM__N24 209.143
RNR1260 TERM_VCM__N19 TERM_VCM__N20 170.429
RNR1261 TERM_VCM__N19 TERM_VCM__N21 179.532
RNR1262 TERM_VCM__N19 TERM_VCM__N22 187.092
RNR1263 TERM_VCM__N19 TERM_VCM__N23 193.196
RNR1264 TERM_VCM__N19 TERM_VCM__N24 198.112
RNR1265 TERM_VCM__N20 TERM_VCM__N21 167.663
RNR1266 TERM_VCM__N20 TERM_VCM__N22 176.227
RNR1267 TERM_VCM__N20 TERM_VCM__N23 182.64
RNR1268 TERM_VCM__N20 TERM_VCM__N24 187.49
RNR1269 TERM_VCM__N21 TERM_VCM__N22 164.377
RNR1270 TERM_VCM__N21 TERM_VCM__N23 171.674
RNR1271 TERM_VCM__N21 TERM_VCM__N24 176.66
RNR1272 TERM_VCM__N22 TERM_VCM__N23 159.363
RNR1273 TERM_VCM__N22 TERM_VCM__N24 164.922
RNR1274 TERM_VCM__N23 TERM_VCM__N24 152.141
RNR1275 PAD_P PAD_P__feed 8.15618
RNR1276 PAD_P PAD_P__dn 2.66354
RNR1277 PAD_P PAD_P__dn 2.65637
RNR1278 PAD_P PAD_P__dn 2.65587
RNR1279 PAD_P PAD_P__dn 2.66061
RNR1280 PAD_P PAD_P__dn 2.67637
RNR1281 PAD_P PAD_P__up 4.94507
RNR1282 PAD_P PAD_P__up 5.66583
RNR1283 PAD_P PAD_P__up 6.3265
RNR1284 PAD_P PAD_P__up 6.84043
RNR1285 PAD_P PAD_P__up 7.14049
RNR1286 PAD_P__feed PAD_P__mim 1.90692
RNR1287 PAD_P__feed PAD_P__h10 1.22391e+06
RNR1288 PAD_P__feed PAD_P__h11 2.59421e+06
RNR1289 PAD_P__feed PAD_P__h12 5.04259e+06
RNR1290 PAD_P__feed PAD_P__h13 7.8244e+06
RNR1291 PAD_P__feed PAD_P__h14 9.73647e+06
RNR1292 PAD_P__feed PAD_P__h15 1.11401e+07
RNR1293 PAD_P__feed PAD_P__h16 1.21755e+07
RNR1294 PAD_P__feed PAD_P__h17 1.30804e+07
RNR1295 PAD_P__feed PAD_P__h18 1.4002e+07
RNR1296 PAD_P__feed PAD_P__h19 1.47986e+07
RNR1297 PAD_P__feed PAD_P__h20 1.55713e+07
RNR1298 PAD_P__feed PAD_P__h21 1.6525e+07
RNR1299 PAD_P__feed PAD_P__h22 1.75858e+07
RNR1300 PAD_P__feed PAD_P__h23 1.84282e+07
RNR1301 PAD_P__feed PAD_P__h24 1.8841e+07
RNR1302 PAD_P__feed PAD_P__h0 375.748
RNR1303 PAD_P__feed PAD_P__h1 758.873
RNR1304 PAD_P__feed PAD_P__h2 1744.94
RNR1305 PAD_P__feed PAD_P__h3 3806.72
RNR1306 PAD_P__feed PAD_P__h4 9059.48
RNR1307 PAD_P__feed PAD_P__h5 20000.1
RNR1308 PAD_P__feed PAD_P__h6 43871.5
RNR1309 PAD_P__feed PAD_P__h7 103409
RNR1310 PAD_P__feed PAD_P__h8 228899
RNR1311 PAD_P__feed PAD_P__h9 556662
RNR1312 PAD_P__feed PAD_P__dn 230.071
RNR1313 PAD_P__feed PAD_P__dn 320.308
RNR1314 PAD_P__feed PAD_P__dn 417.766
RNR1315 PAD_P__feed PAD_P__dn 504.425
RNR1316 PAD_P__feed PAD_P__dn 554.524
RNR1317 PAD_P__feed PAD_P__up 45.0486
RNR1318 PAD_P__feed PAD_P__up 51.6452
RNR1319 PAD_P__feed PAD_P__up 57.67
RNR1320 PAD_P__feed PAD_P__up 62.355
RNR1321 PAD_P__feed PAD_P__up 65.0903
RNR1322 PAD_P__mim PAD_P__h10 14.6156
RNR1323 PAD_P__mim PAD_P__h11 14.8947
RNR1324 PAD_P__mim PAD_P__h12 15.4466
RNR1325 PAD_P__mim PAD_P__h13 16.5547
RNR1326 PAD_P__mim PAD_P__h14 17.8339
RNR1327 PAD_P__mim PAD_P__h15 19.3327
RNR1328 PAD_P__mim PAD_P__h16 20.774
RNR1329 PAD_P__mim PAD_P__h17 22.1928
RNR1330 PAD_P__mim PAD_P__h18 23.7088
RNR1331 PAD_P__mim PAD_P__h19 25.0432
RNR1332 PAD_P__mim PAD_P__h20 26.3458
RNR1333 PAD_P__mim PAD_P__h21 27.9579
RNR1334 PAD_P__mim PAD_P__h22 29.7527
RNR1335 PAD_P__mim PAD_P__h23 31.1779
RNR1336 PAD_P__mim PAD_P__h24 31.8762
RNR1337 PAD_P__mim PAD_P__h0 14.4835
RNR1338 PAD_P__mim PAD_P__h1 14.2311
RNR1339 PAD_P__mim PAD_P__h2 14.0937
RNR1340 PAD_P__mim PAD_P__h3 14.0393
RNR1341 PAD_P__mim PAD_P__h4 14.0107
RNR1342 PAD_P__mim PAD_P__h5 14.0121
RNR1343 PAD_P__mim PAD_P__h6 14.0072
RNR1344 PAD_P__mim PAD_P__h7 14.012
RNR1345 PAD_P__mim PAD_P__h8 14.0263
RNR1346 PAD_P__mim PAD_P__h9 13.2624
RNR1347 PAD_P__h10 PAD_P__h11 2159.23
RNR1348 PAD_P__h10 PAD_P__h12 4209.01
RNR1349 PAD_P__h10 PAD_P__h13 6543.59
RNR1350 PAD_P__h10 PAD_P__h14 8150.57
RNR1351 PAD_P__h10 PAD_P__h15 9329.27
RNR1352 PAD_P__h10 PAD_P__h16 10197.7
RNR1353 PAD_P__h10 PAD_P__h17 10956.1
RNR1354 PAD_P__h10 PAD_P__h18 11728.3
RNR1355 PAD_P__h10 PAD_P__h19 12395.5
RNR1356 PAD_P__h10 PAD_P__h20 13042.8
RNR1357 PAD_P__h10 PAD_P__h21 13841.6
RNR1358 PAD_P__h10 PAD_P__h22 14730.2
RNR1359 PAD_P__h10 PAD_P__h23 15435.8
RNR1360 PAD_P__h10 PAD_P__h24 15781.5
RNR1361 PAD_P__h10 PAD_P__h0 2.71325e+06
RNR1362 PAD_P__h10 PAD_P__h1 1.51026e+06
RNR1363 PAD_P__h10 PAD_P__h2 674778
RNR1364 PAD_P__h10 PAD_P__h3 308249
RNR1365 PAD_P__h10 PAD_P__h4 130867
RNR1366 PAD_P__h10 PAD_P__h5 58383.4
RNR1367 PAD_P__h10 PAD_P__h6 26697.4
RNR1368 PAD_P__h10 PAD_P__h7 11315.4
RNR1369 PAD_P__h10 PAD_P__h8 5153.25
RNR1370 PAD_P__h10 PAD_P__h9 2522.84
RNR1371 PAD_P__h11 PAD_P__h12 1876.79
RNR1372 PAD_P__h11 PAD_P__h13 2933.71
RNR1373 PAD_P__h11 PAD_P__h14 3664.22
RNR1374 PAD_P__h11 PAD_P__h15 4198.89
RNR1375 PAD_P__h11 PAD_P__h16 4591.46
RNR1376 PAD_P__h11 PAD_P__h17 4933.53
RNR1377 PAD_P__h11 PAD_P__h18 5281.48
RNR1378 PAD_P__h11 PAD_P__h19 5582.04
RNR1379 PAD_P__h11 PAD_P__h20 5873.55
RNR1380 PAD_P__h11 PAD_P__h21 6233.27
RNR1381 PAD_P__h11 PAD_P__h22 6633.43
RNR1382 PAD_P__h11 PAD_P__h23 6951.18
RNR1383 PAD_P__h11 PAD_P__h24 7106.88
RNR1384 PAD_P__h11 PAD_P__h0 5.75102e+06
RNR1385 PAD_P__h11 PAD_P__h1 3.20115e+06
RNR1386 PAD_P__h11 PAD_P__h2 1.43026e+06
RNR1387 PAD_P__h11 PAD_P__h3 653367
RNR1388 PAD_P__h11 PAD_P__h4 277386
RNR1389 PAD_P__h11 PAD_P__h5 123751
RNR1390 PAD_P__h11 PAD_P__h6 56590.3
RNR1391 PAD_P__h11 PAD_P__h7 23988.1
RNR1392 PAD_P__h11 PAD_P__h8 10928.5
RNR1393 PAD_P__h11 PAD_P__h9 5355.32
RNR1394 PAD_P__h12 PAD_P__h13 1370.45
RNR1395 PAD_P__h12 PAD_P__h14 1728.88
RNR1396 PAD_P__h12 PAD_P__h15 1989.45
RNR1397 PAD_P__h12 PAD_P__h16 2178.42
RNR1398 PAD_P__h12 PAD_P__h17 2341.79
RNR1399 PAD_P__h12 PAD_P__h18 2507.37
RNR1400 PAD_P__h12 PAD_P__h19 2650.18
RNR1401 PAD_P__h12 PAD_P__h20 2788.62
RNR1402 PAD_P__h12 PAD_P__h21 2959.42
RNR1403 PAD_P__h12 PAD_P__h22 3149.41
RNR1404 PAD_P__h12 PAD_P__h23 3300.27
RNR1405 PAD_P__h12 PAD_P__h24 3374.19
RNR1406 PAD_P__h12 PAD_P__h0 1.11788e+07
RNR1407 PAD_P__h12 PAD_P__h1 6.22235e+06
RNR1408 PAD_P__h12 PAD_P__h2 2.78013e+06
RNR1409 PAD_P__h12 PAD_P__h3 1.27001e+06
RNR1410 PAD_P__h12 PAD_P__h4 539180
RNR1411 PAD_P__h12 PAD_P__h5 240547
RNR1412 PAD_P__h12 PAD_P__h6 110001
RNR1413 PAD_P__h12 PAD_P__h7 46630.8
RNR1414 PAD_P__h12 PAD_P__h8 21246.9
RNR1415 PAD_P__h12 PAD_P__h9 10415.6
RNR1416 PAD_P__h13 PAD_P__h14 849.509
RNR1417 PAD_P__h13 PAD_P__h15 999.228
RNR1418 PAD_P__h13 PAD_P__h16 1102.17
RNR1419 PAD_P__h13 PAD_P__h17 1187.75
RNR1420 PAD_P__h13 PAD_P__h18 1272.86
RNR1421 PAD_P__h13 PAD_P__h19 1345.7
RNR1422 PAD_P__h13 PAD_P__h20 1416.12
RNR1423 PAD_P__h13 PAD_P__h21 1502.89
RNR1424 PAD_P__h13 PAD_P__h22 1599.37
RNR1425 PAD_P__h13 PAD_P__h23 1675.99
RNR1426 PAD_P__h13 PAD_P__h24 1713.53
RNR1427 PAD_P__h13 PAD_P__h0 1.73457e+07
RNR1428 PAD_P__h13 PAD_P__h1 9.655e+06
RNR1429 PAD_P__h13 PAD_P__h2 4.31382e+06
RNR1430 PAD_P__h13 PAD_P__h3 1.97063e+06
RNR1431 PAD_P__h13 PAD_P__h4 836627
RNR1432 PAD_P__h13 PAD_P__h5 373249
RNR1433 PAD_P__h13 PAD_P__h6 170687
RNR1434 PAD_P__h13 PAD_P__h7 72358.4
RNR1435 PAD_P__h13 PAD_P__h8 32972.6
RNR1436 PAD_P__h13 PAD_P__h9 16167.9
RNR1437 PAD_P__h14 PAD_P__h15 624.625
RNR1438 PAD_P__h14 PAD_P__h16 703.707
RNR1439 PAD_P__h14 PAD_P__h17 763.891
RNR1440 PAD_P__h14 PAD_P__h18 820.797
RNR1441 PAD_P__h14 PAD_P__h19 868.425
RNR1442 PAD_P__h14 PAD_P__h20 914.099
RNR1443 PAD_P__h14 PAD_P__h21 970.174
RNR1444 PAD_P__h14 PAD_P__h22 1032.46
RNR1445 PAD_P__h14 PAD_P__h23 1081.91
RNR1446 PAD_P__h14 PAD_P__h24 1106.15
RNR1447 PAD_P__h14 PAD_P__h0 2.15845e+07
RNR1448 PAD_P__h14 PAD_P__h1 1.20144e+07
RNR1449 PAD_P__h14 PAD_P__h2 5.36801e+06
RNR1450 PAD_P__h14 PAD_P__h3 2.4522e+06
RNR1451 PAD_P__h14 PAD_P__h4 1.04108e+06
RNR1452 PAD_P__h14 PAD_P__h5 464462
RNR1453 PAD_P__h14 PAD_P__h6 212399
RNR1454 PAD_P__h14 PAD_P__h7 90042.9
RNR1455 PAD_P__h14 PAD_P__h8 41033.1
RNR1456 PAD_P__h14 PAD_P__h9 20122.9
RNR1457 PAD_P__h15 PAD_P__h16 483.37
RNR1458 PAD_P__h15 PAD_P__h17 536.368
RNR1459 PAD_P__h15 PAD_P__h18 581.036
RNR1460 PAD_P__h15 PAD_P__h19 616.196
RNR1461 PAD_P__h15 PAD_P__h20 649.111
RNR1462 PAD_P__h15 PAD_P__h21 689.076
RNR1463 PAD_P__h15 PAD_P__h22 733.315
RNR1464 PAD_P__h15 PAD_P__h23 768.442
RNR1465 PAD_P__h15 PAD_P__h24 785.654
RNR1466 PAD_P__h15 PAD_P__h0 2.46961e+07
RNR1467 PAD_P__h15 PAD_P__h1 1.37464e+07
RNR1468 PAD_P__h15 PAD_P__h2 6.14185e+06
RNR1469 PAD_P__h15 PAD_P__h3 2.8057e+06
RNR1470 PAD_P__h15 PAD_P__h4 1.19116e+06
RNR1471 PAD_P__h15 PAD_P__h5 531418
RNR1472 PAD_P__h15 PAD_P__h6 243019
RNR1473 PAD_P__h15 PAD_P__h7 103024
RNR1474 PAD_P__h15 PAD_P__h8 46949.6
RNR1475 PAD_P__h15 PAD_P__h9 23025.7
RNR1476 PAD_P__h16 PAD_P__h17 406.107
RNR1477 PAD_P__h16 PAD_P__h18 448.668
RNR1478 PAD_P__h16 PAD_P__h19 478.573
RNR1479 PAD_P__h16 PAD_P__h20 505.113
RNR1480 PAD_P__h16 PAD_P__h21 536.494
RNR1481 PAD_P__h16 PAD_P__h22 570.939
RNR1482 PAD_P__h16 PAD_P__h23 598.288
RNR1483 PAD_P__h16 PAD_P__h24 611.689
RNR1484 PAD_P__h16 PAD_P__h0 2.69915e+07
RNR1485 PAD_P__h16 PAD_P__h1 1.5024e+07
RNR1486 PAD_P__h16 PAD_P__h2 6.7127e+06
RNR1487 PAD_P__h16 PAD_P__h3 3.06647e+06
RNR1488 PAD_P__h16 PAD_P__h4 1.30187e+06
RNR1489 PAD_P__h16 PAD_P__h5 580810
RNR1490 PAD_P__h16 PAD_P__h6 265606
RNR1491 PAD_P__h16 PAD_P__h7 112600
RNR1492 PAD_P__h16 PAD_P__h8 51313.8
RNR1493 PAD_P__h16 PAD_P__h9 25166.4
RNR1494 PAD_P__h17 PAD_P__h18 356.583
RNR1495 PAD_P__h17 PAD_P__h19 386.165
RNR1496 PAD_P__h17 PAD_P__h20 409.685
RNR1497 PAD_P__h17 PAD_P__h21 435.749
RNR1498 PAD_P__h17 PAD_P__h22 463.731
RNR1499 PAD_P__h17 PAD_P__h23 485.945
RNR1500 PAD_P__h17 PAD_P__h24 496.829
RNR1501 PAD_P__h17 PAD_P__h0 2.89975e+07
RNR1502 PAD_P__h17 PAD_P__h1 1.61406e+07
RNR1503 PAD_P__h17 PAD_P__h2 7.21159e+06
RNR1504 PAD_P__h17 PAD_P__h3 3.29437e+06
RNR1505 PAD_P__h17 PAD_P__h4 1.39862e+06
RNR1506 PAD_P__h17 PAD_P__h5 623976
RNR1507 PAD_P__h17 PAD_P__h6 285346
RNR1508 PAD_P__h17 PAD_P__h7 120969
RNR1509 PAD_P__h17 PAD_P__h8 55127.7
RNR1510 PAD_P__h17 PAD_P__h9 27037.1
RNR1511 PAD_P__h18 PAD_P__h19 310.17
RNR1512 PAD_P__h18 PAD_P__h20 334.263
RNR1513 PAD_P__h18 PAD_P__h21 357.073
RNR1514 PAD_P__h18 PAD_P__h22 380.016
RNR1515 PAD_P__h18 PAD_P__h23 398.219
RNR1516 PAD_P__h18 PAD_P__h24 407.139
RNR1517 PAD_P__h18 PAD_P__h0 3.10407e+07
RNR1518 PAD_P__h18 PAD_P__h1 1.7278e+07
RNR1519 PAD_P__h18 PAD_P__h2 7.71974e+06
RNR1520 PAD_P__h18 PAD_P__h3 3.52651e+06
RNR1521 PAD_P__h18 PAD_P__h4 1.49717e+06
RNR1522 PAD_P__h18 PAD_P__h5 667944
RNR1523 PAD_P__h18 PAD_P__h6 305453
RNR1524 PAD_P__h18 PAD_P__h7 129493
RNR1525 PAD_P__h18 PAD_P__h8 59012.2
RNR1526 PAD_P__h18 PAD_P__h9 28942.3
RNR1527 PAD_P__h19 PAD_P__h20 279.432
RNR1528 PAD_P__h19 PAD_P__h21 301.832
RNR1529 PAD_P__h19 PAD_P__h22 321.254
RNR1530 PAD_P__h19 PAD_P__h23 336.643
RNR1531 PAD_P__h19 PAD_P__h24 344.183
RNR1532 PAD_P__h19 PAD_P__h0 3.28066e+07
RNR1533 PAD_P__h19 PAD_P__h1 1.82609e+07
RNR1534 PAD_P__h19 PAD_P__h2 8.15891e+06
RNR1535 PAD_P__h19 PAD_P__h3 3.72712e+06
RNR1536 PAD_P__h19 PAD_P__h4 1.58235e+06
RNR1537 PAD_P__h19 PAD_P__h5 705943
RNR1538 PAD_P__h19 PAD_P__h6 322830
RNR1539 PAD_P__h19 PAD_P__h7 136859
RNR1540 PAD_P__h19 PAD_P__h8 62369.4
RNR1541 PAD_P__h19 PAD_P__h9 30588.8
RNR1542 PAD_P__h20 PAD_P__h21 254.121
RNR1543 PAD_P__h20 PAD_P__h22 270.539
RNR1544 PAD_P__h20 PAD_P__h23 283.498
RNR1545 PAD_P__h20 PAD_P__h24 289.848
RNR1546 PAD_P__h20 PAD_P__h0 3.45197e+07
RNR1547 PAD_P__h20 PAD_P__h1 1.92144e+07
RNR1548 PAD_P__h20 PAD_P__h2 8.58495e+06
RNR1549 PAD_P__h20 PAD_P__h3 3.92175e+06
RNR1550 PAD_P__h20 PAD_P__h4 1.66497e+06
RNR1551 PAD_P__h20 PAD_P__h5 742805
RNR1552 PAD_P__h20 PAD_P__h6 339687
RNR1553 PAD_P__h20 PAD_P__h7 144006
RNR1554 PAD_P__h20 PAD_P__h8 65626.2
RNR1555 PAD_P__h20 PAD_P__h9 32186.1
RNR1556 PAD_P__h21 PAD_P__h22 217.302
RNR1557 PAD_P__h21 PAD_P__h23 227.711
RNR1558 PAD_P__h21 PAD_P__h24 232.812
RNR1559 PAD_P__h21 PAD_P__h0 3.66337e+07
RNR1560 PAD_P__h21 PAD_P__h1 2.03912e+07
RNR1561 PAD_P__h21 PAD_P__h2 9.11071e+06
RNR1562 PAD_P__h21 PAD_P__h3 4.16192e+06
RNR1563 PAD_P__h21 PAD_P__h4 1.76694e+06
RNR1564 PAD_P__h21 PAD_P__h5 788296
RNR1565 PAD_P__h21 PAD_P__h6 360490
RNR1566 PAD_P__h21 PAD_P__h7 152825
RNR1567 PAD_P__h21 PAD_P__h8 69645.2
RNR1568 PAD_P__h21 PAD_P__h9 34157.2
RNR1569 PAD_P__h22 PAD_P__h23 179.755
RNR1570 PAD_P__h22 PAD_P__h24 183.782
RNR1571 PAD_P__h22 PAD_P__h0 3.89855e+07
RNR1572 PAD_P__h22 PAD_P__h1 2.17002e+07
RNR1573 PAD_P__h22 PAD_P__h2 9.6956e+06
RNR1574 PAD_P__h22 PAD_P__h3 4.42911e+06
RNR1575 PAD_P__h22 PAD_P__h4 1.88037e+06
RNR1576 PAD_P__h22 PAD_P__h5 838903
RNR1577 PAD_P__h22 PAD_P__h6 383633
RNR1578 PAD_P__h22 PAD_P__h7 162636
RNR1579 PAD_P__h22 PAD_P__h8 74116.3
RNR1580 PAD_P__h22 PAD_P__h9 36350
RNR1581 PAD_P__h23 PAD_P__h24 146.658
RNR1582 PAD_P__h23 PAD_P__h0 4.0853e+07
RNR1583 PAD_P__h23 PAD_P__h1 2.27397e+07
RNR1584 PAD_P__h23 PAD_P__h2 1.016e+07
RNR1585 PAD_P__h23 PAD_P__h3 4.64127e+06
RNR1586 PAD_P__h23 PAD_P__h4 1.97045e+06
RNR1587 PAD_P__h23 PAD_P__h5 879088
RNR1588 PAD_P__h23 PAD_P__h6 402009
RNR1589 PAD_P__h23 PAD_P__h7 170426
RNR1590 PAD_P__h23 PAD_P__h8 77666.6
RNR1591 PAD_P__h23 PAD_P__h9 38091.3
RNR1592 PAD_P__h24 PAD_P__h0 4.17681e+07
RNR1593 PAD_P__h24 PAD_P__h1 2.3249e+07
RNR1594 PAD_P__h24 PAD_P__h2 1.03876e+07
RNR1595 PAD_P__h24 PAD_P__h3 4.74523e+06
RNR1596 PAD_P__h24 PAD_P__h4 2.01458e+06
RNR1597 PAD_P__h24 PAD_P__h5 898778
RNR1598 PAD_P__h24 PAD_P__h6 411014
RNR1599 PAD_P__h24 PAD_P__h7 174244
RNR1600 PAD_P__h24 PAD_P__h8 79406.2
RNR1601 PAD_P__h24 PAD_P__h9 38944.5
RNR1602 PAD_P__h0 PAD_P__h1 1628.02
RNR1603 PAD_P__h0 PAD_P__h2 3836.7
RNR1604 PAD_P__h0 PAD_P__h3 8419.88
RNR1605 PAD_P__h0 PAD_P__h4 20072.2
RNR1606 PAD_P__h0 PAD_P__h5 44330
RNR1607 PAD_P__h0 PAD_P__h6 97252.7
RNR1608 PAD_P__h0 PAD_P__h7 229242
RNR1609 PAD_P__h0 PAD_P__h8 507437
RNR1610 PAD_P__h0 PAD_P__h9 1.23405e+06
RNR1611 PAD_P__h1 PAD_P__h2 2130.9
RNR1612 PAD_P__h1 PAD_P__h3 4683.83
RNR1613 PAD_P__h1 PAD_P__h4 11170.9
RNR1614 PAD_P__h1 PAD_P__h5 24673.9
RNR1615 PAD_P__h1 PAD_P__h6 54132.3
RNR1616 PAD_P__h1 PAD_P__h7 127601
RNR1617 PAD_P__h1 PAD_P__h8 282451
RNR1618 PAD_P__h1 PAD_P__h9 686898
RNR1619 PAD_P__h2 PAD_P__h3 2088.22
RNR1620 PAD_P__h2 PAD_P__h4 4988.41
RNR1621 PAD_P__h2 PAD_P__h5 11022.4
RNR1622 PAD_P__h2 PAD_P__h6 24185
RNR1623 PAD_P__h2 PAD_P__h7 57011
RNR1624 PAD_P__h2 PAD_P__h8 126198
RNR1625 PAD_P__h2 PAD_P__h9 306904
RNR1626 PAD_P__h3 PAD_P__h4 2274.48
RNR1627 PAD_P__h3 PAD_P__h5 5032.36
RNR1628 PAD_P__h3 PAD_P__h6 11046.3
RNR1629 PAD_P__h3 PAD_P__h7 26042.5
RNR1630 PAD_P__h3 PAD_P__h8 57648.6
RNR1631 PAD_P__h3 PAD_P__h9 140198
RNR1632 PAD_P__h4 PAD_P__h5 2131.4
RNR1633 PAD_P__h4 PAD_P__h6 4686.49
RNR1634 PAD_P__h4 PAD_P__h7 11054.5
RNR1635 PAD_P__h4 PAD_P__h8 24473.5
RNR1636 PAD_P__h4 PAD_P__h9 59520.4
RNR1637 PAD_P__h5 PAD_P__h6 2085.55
RNR1638 PAD_P__h5 PAD_P__h7 4928.85
RNR1639 PAD_P__h5 PAD_P__h8 10916.7
RNR1640 PAD_P__h5 PAD_P__h9 26553.1
RNR1641 PAD_P__h6 PAD_P__h7 2248.94
RNR1642 PAD_P__h6 PAD_P__h8 4989.12
RNR1643 PAD_P__h6 PAD_P__h9 12140.9
RNR1644 PAD_P__h7 PAD_P__h8 2109.63
RNR1645 PAD_P__h7 PAD_P__h9 5143.67
RNR1646 PAD_P__h8 PAD_P__h9 2339.72
RNR1647 PAD_P__dn PAD_P__up 139.491
RNR1648 PAD_P__dn PAD_P__up 159.823
RNR1649 PAD_P__dn PAD_P__up 178.459
RNR1650 PAD_P__dn PAD_P__up 192.956
RNR1651 PAD_P__dn PAD_P__up 201.42
RNR1652 PAD_P__dn PAD_P__up 194.202
RNR1653 PAD_P__dn PAD_P__up 222.507
RNR1654 PAD_P__dn PAD_P__up 248.453
RNR1655 PAD_P__dn PAD_P__up 268.636
RNR1656 PAD_P__dn PAD_P__up 280.42
RNR1657 PAD_P__dn PAD_P__up 253.29
RNR1658 PAD_P__dn PAD_P__up 290.208
RNR1659 PAD_P__dn PAD_P__up 324.048
RNR1660 PAD_P__dn PAD_P__up 350.372
RNR1661 PAD_P__dn PAD_P__up 365.742
RNR1662 PAD_P__dn PAD_P__up 305.831
RNR1663 PAD_P__dn PAD_P__up 350.407
RNR1664 PAD_P__dn PAD_P__up 391.267
RNR1665 PAD_P__dn PAD_P__up 423.051
RNR1666 PAD_P__dn PAD_P__up 441.609
RNR1667 PAD_P__dn PAD_P__up 336.206
RNR1668 PAD_P__dn PAD_P__up 385.209
RNR1669 PAD_P__dn PAD_P__up 430.127
RNR1670 PAD_P__dn PAD_P__up 465.068
RNR1671 PAD_P__dn PAD_P__up 485.469
RNR1672 RX_P RX_P__mim 238.281
RNR1673 RX_P RX_P__dev 211.354
RNR1674 RX_P RX_P__dev 255.701
RNR1675 RX_P RX_P__dev 264.074
RNR1676 RX_P__mim RX_P__dev 144.845
RNR1677 RX_P__mim RX_P__dev 162.641
RNR1678 RX_P__mim RX_P__dev 155.85
RNR1679 PAD_N PAD_N__feed 9.5434
RNR1680 PAD_N PAD_N__dn 2.66112
RNR1681 PAD_N PAD_N__dn 2.65464
RNR1682 PAD_N PAD_N__dn 2.65454
RNR1683 PAD_N PAD_N__dn 2.65951
RNR1684 PAD_N PAD_N__dn 2.67536
RNR1685 PAD_N PAD_N__up 4.90274
RNR1686 PAD_N PAD_N__up 5.61735
RNR1687 PAD_N PAD_N__up 6.27237
RNR1688 PAD_N PAD_N__up 6.7819
RNR1689 PAD_N PAD_N__up 7.0794
RNR1690 PAD_N__feed PAD_N__mim 0.799162
RNR1691 PAD_N__feed PAD_N__h0 157.433
RNR1692 PAD_N__feed PAD_N__h1 318.005
RNR1693 PAD_N__feed PAD_N__h2 731.245
RNR1694 PAD_N__feed PAD_N__h3 1595.31
RNR1695 PAD_N__feed PAD_N__h4 3796.67
RNR1696 PAD_N__feed PAD_N__h5 8381.84
RNR1697 PAD_N__feed PAD_N__h6 18386.5
RNR1698 PAD_N__feed PAD_N__h7 43338.8
RNR1699 PAD_N__feed PAD_N__h8 95933.2
RNR1700 PAD_N__feed PAD_N__h9 233306
RNR1701 PAD_N__feed PAD_N__h10 512967
RNR1702 PAD_N__feed PAD_N__h11 1.0873e+06
RNR1703 PAD_N__feed PAD_N__h12 2.1135e+06
RNR1704 PAD_N__feed PAD_N__h13 3.27951e+06
RNR1705 PAD_N__feed PAD_N__h14 4.08093e+06
RNR1706 PAD_N__feed PAD_N__h15 4.66921e+06
RNR1707 PAD_N__feed PAD_N__h16 5.10318e+06
RNR1708 PAD_N__feed PAD_N__h17 5.48245e+06
RNR1709 PAD_N__feed PAD_N__h18 5.86876e+06
RNR1710 PAD_N__feed PAD_N__h19 6.20263e+06
RNR1711 PAD_N__feed PAD_N__h20 6.52651e+06
RNR1712 PAD_N__feed PAD_N__h21 6.9262e+06
RNR1713 PAD_N__feed PAD_N__h22 7.37086e+06
RNR1714 PAD_N__feed PAD_N__h23 7.72393e+06
RNR1715 PAD_N__feed PAD_N__h24 7.89696e+06
RNR1716 PAD_N__feed PAD_N__dn 269.202
RNR1717 PAD_N__feed PAD_N__dn 374.787
RNR1718 PAD_N__feed PAD_N__dn 488.821
RNR1719 PAD_N__feed PAD_N__dn 590.219
RNR1720 PAD_N__feed PAD_N__dn 648.839
RNR1721 PAD_N__feed PAD_N__up 52.7105
RNR1722 PAD_N__feed PAD_N__up 60.4291
RNR1723 PAD_N__feed PAD_N__up 67.4786
RNR1724 PAD_N__feed PAD_N__up 72.9604
RNR1725 PAD_N__feed PAD_N__up 76.161
RNR1726 PAD_N__mim PAD_N__h0 15.2933
RNR1727 PAD_N__mim PAD_N__h1 14.6074
RNR1728 PAD_N__mim PAD_N__h2 14.2518
RNR1729 PAD_N__mim PAD_N__h3 14.1108
RNR1730 PAD_N__mim PAD_N__h4 14.0406
RNR1731 PAD_N__mim PAD_N__h5 14.0256
RNR1732 PAD_N__mim PAD_N__h6 14.0134
RNR1733 PAD_N__mim PAD_N__h7 14.0147
RNR1734 PAD_N__mim PAD_N__h8 14.0276
RNR1735 PAD_N__mim PAD_N__h9 13.2628
RNR1736 PAD_N__mim PAD_N__h10 14.6158
RNR1737 PAD_N__mim PAD_N__h11 14.8948
RNR1738 PAD_N__mim PAD_N__h12 15.4467
RNR1739 PAD_N__mim PAD_N__h13 16.5548
RNR1740 PAD_N__mim PAD_N__h14 17.834
RNR1741 PAD_N__mim PAD_N__h15 19.3327
RNR1742 PAD_N__mim PAD_N__h16 20.7741
RNR1743 PAD_N__mim PAD_N__h17 22.1929
RNR1744 PAD_N__mim PAD_N__h18 23.7089
RNR1745 PAD_N__mim PAD_N__h19 25.0433
RNR1746 PAD_N__mim PAD_N__h20 26.3459
RNR1747 PAD_N__mim PAD_N__h21 27.9579
RNR1748 PAD_N__mim PAD_N__h22 29.7528
RNR1749 PAD_N__mim PAD_N__h23 31.178
RNR1750 PAD_N__mim PAD_N__h24 31.8764
RNR1751 PAD_N__h0 PAD_N__h1 1652.83
RNR1752 PAD_N__h0 PAD_N__h2 3896.68
RNR1753 PAD_N__h0 PAD_N__h3 8552.43
RNR1754 PAD_N__h0 PAD_N__h4 20389
RNR1755 PAD_N__h0 PAD_N__h5 45030.7
RNR1756 PAD_N__h0 PAD_N__h6 98792.3
RNR1757 PAD_N__h0 PAD_N__h7 232872
RNR1758 PAD_N__h0 PAD_N__h8 515482
RNR1759 PAD_N__h0 PAD_N__h9 1.25363e+06
RNR1760 PAD_N__h0 PAD_N__h10 2.75636e+06
RNR1761 PAD_N__h0 PAD_N__h11 5.84247e+06
RNR1762 PAD_N__h0 PAD_N__h12 1.13566e+07
RNR1763 PAD_N__h0 PAD_N__h13 1.7622e+07
RNR1764 PAD_N__h0 PAD_N__h14 2.19283e+07
RNR1765 PAD_N__h0 PAD_N__h15 2.50893e+07
RNR1766 PAD_N__h0 PAD_N__h16 2.74212e+07
RNR1767 PAD_N__h0 PAD_N__h17 2.94592e+07
RNR1768 PAD_N__h0 PAD_N__h18 3.1535e+07
RNR1769 PAD_N__h0 PAD_N__h19 3.3329e+07
RNR1770 PAD_N__h0 PAD_N__h20 3.50693e+07
RNR1771 PAD_N__h0 PAD_N__h21 3.7217e+07
RNR1772 PAD_N__h0 PAD_N__h22 3.96063e+07
RNR1773 PAD_N__h0 PAD_N__h23 4.15034e+07
RNR1774 PAD_N__h0 PAD_N__h24 4.24332e+07
RNR1775 PAD_N__h1 PAD_N__h2 2140.04
RNR1776 PAD_N__h1 PAD_N__h3 4704.14
RNR1777 PAD_N__h1 PAD_N__h4 11219.6
RNR1778 PAD_N__h1 PAD_N__h5 24781.9
RNR1779 PAD_N__h1 PAD_N__h6 54370.4
RNR1780 PAD_N__h1 PAD_N__h7 128163
RNR1781 PAD_N__h1 PAD_N__h8 283699
RNR1782 PAD_N__h1 PAD_N__h9 689947
RNR1783 PAD_N__h1 PAD_N__h10 1.51698e+06
RNR1784 PAD_N__h1 PAD_N__h11 3.21545e+06
RNR1785 PAD_N__h1 PAD_N__h12 6.25019e+06
RNR1786 PAD_N__h1 PAD_N__h13 9.6984e+06
RNR1787 PAD_N__h1 PAD_N__h14 1.20684e+07
RNR1788 PAD_N__h1 PAD_N__h15 1.38081e+07
RNR1789 PAD_N__h1 PAD_N__h16 1.50915e+07
RNR1790 PAD_N__h1 PAD_N__h17 1.62131e+07
RNR1791 PAD_N__h1 PAD_N__h18 1.73555e+07
RNR1792 PAD_N__h1 PAD_N__h19 1.83428e+07
RNR1793 PAD_N__h1 PAD_N__h20 1.93007e+07
RNR1794 PAD_N__h1 PAD_N__h21 2.04826e+07
RNR1795 PAD_N__h1 PAD_N__h22 2.17976e+07
RNR1796 PAD_N__h1 PAD_N__h23 2.28417e+07
RNR1797 PAD_N__h1 PAD_N__h24 2.33534e+07
RNR1798 PAD_N__h2 PAD_N__h3 2090.06
RNR1799 PAD_N__h2 PAD_N__h4 4992.88
RNR1800 PAD_N__h2 PAD_N__h5 11032.5
RNR1801 PAD_N__h2 PAD_N__h6 24207.6
RNR1802 PAD_N__h2 PAD_N__h7 57064.5
RNR1803 PAD_N__h2 PAD_N__h8 126318
RNR1804 PAD_N__h2 PAD_N__h9 307202
RNR1805 PAD_N__h2 PAD_N__h10 675444
RNR1806 PAD_N__h2 PAD_N__h11 1.4317e+06
RNR1807 PAD_N__h2 PAD_N__h12 2.78293e+06
RNR1808 PAD_N__h2 PAD_N__h13 4.31826e+06
RNR1809 PAD_N__h2 PAD_N__h14 5.37352e+06
RNR1810 PAD_N__h2 PAD_N__h15 6.14813e+06
RNR1811 PAD_N__h2 PAD_N__h16 6.71957e+06
RNR1812 PAD_N__h2 PAD_N__h17 7.21896e+06
RNR1813 PAD_N__h2 PAD_N__h18 7.72764e+06
RNR1814 PAD_N__h2 PAD_N__h19 8.16725e+06
RNR1815 PAD_N__h2 PAD_N__h20 8.59372e+06
RNR1816 PAD_N__h2 PAD_N__h21 9.12e+06
RNR1817 PAD_N__h2 PAD_N__h22 9.7055e+06
RNR1818 PAD_N__h2 PAD_N__h23 1.01704e+07
RNR1819 PAD_N__h2 PAD_N__h24 1.03982e+07
RNR1820 PAD_N__h3 PAD_N__h4 2275
RNR1821 PAD_N__h3 PAD_N__h5 5033.56
RNR1822 PAD_N__h3 PAD_N__h6 11049.2
RNR1823 PAD_N__h3 PAD_N__h7 26049.5
RNR1824 PAD_N__h3 PAD_N__h8 57664.8
RNR1825 PAD_N__h3 PAD_N__h9 140241
RNR1826 PAD_N__h3 PAD_N__h10 308346
RNR1827 PAD_N__h3 PAD_N__h11 653583
RNR1828 PAD_N__h3 PAD_N__h12 1.27043e+06
RNR1829 PAD_N__h3 PAD_N__h13 1.97133e+06
RNR1830 PAD_N__h3 PAD_N__h14 2.45306e+06
RNR1831 PAD_N__h3 PAD_N__h15 2.80668e+06
RNR1832 PAD_N__h3 PAD_N__h16 3.06755e+06
RNR1833 PAD_N__h3 PAD_N__h17 3.29553e+06
RNR1834 PAD_N__h3 PAD_N__h18 3.52774e+06
RNR1835 PAD_N__h3 PAD_N__h19 3.72843e+06
RNR1836 PAD_N__h3 PAD_N__h20 3.92312e+06
RNR1837 PAD_N__h3 PAD_N__h21 4.16337e+06
RNR1838 PAD_N__h3 PAD_N__h22 4.43065e+06
RNR1839 PAD_N__h3 PAD_N__h23 4.64289e+06
RNR1840 PAD_N__h3 PAD_N__h24 4.7469e+06
RNR1841 PAD_N__h4 PAD_N__h5 2131.58
RNR1842 PAD_N__h4 PAD_N__h6 4686.97
RNR1843 PAD_N__h4 PAD_N__h7 11055.7
RNR1844 PAD_N__h4 PAD_N__h8 24476.6
RNR1845 PAD_N__h4 PAD_N__h9 59528.9
RNR1846 PAD_N__h4 PAD_N__h10 130887
RNR1847 PAD_N__h4 PAD_N__h11 277433
RNR1848 PAD_N__h4 PAD_N__h12 539276
RNR1849 PAD_N__h4 PAD_N__h13 836793
RNR1850 PAD_N__h4 PAD_N__h14 1.04128e+06
RNR1851 PAD_N__h4 PAD_N__h15 1.19139e+06
RNR1852 PAD_N__h4 PAD_N__h16 1.30212e+06
RNR1853 PAD_N__h4 PAD_N__h17 1.39889e+06
RNR1854 PAD_N__h4 PAD_N__h18 1.49746e+06
RNR1855 PAD_N__h4 PAD_N__h19 1.58265e+06
RNR1856 PAD_N__h4 PAD_N__h20 1.66529e+06
RNR1857 PAD_N__h4 PAD_N__h21 1.76728e+06
RNR1858 PAD_N__h4 PAD_N__h22 1.88073e+06
RNR1859 PAD_N__h4 PAD_N__h23 1.97082e+06
RNR1860 PAD_N__h4 PAD_N__h24 2.01497e+06
RNR1861 PAD_N__h5 PAD_N__h6 2085.69
RNR1862 PAD_N__h5 PAD_N__h7 4929.18
RNR1863 PAD_N__h5 PAD_N__h8 10917.6
RNR1864 PAD_N__h5 PAD_N__h9 26555.7
RNR1865 PAD_N__h5 PAD_N__h10 58390
RNR1866 PAD_N__h5 PAD_N__h11 123767
RNR1867 PAD_N__h5 PAD_N__h12 240579
RNR1868 PAD_N__h5 PAD_N__h13 373307
RNR1869 PAD_N__h5 PAD_N__h14 464533
RNR1870 PAD_N__h5 PAD_N__h15 531498
RNR1871 PAD_N__h5 PAD_N__h16 580897
RNR1872 PAD_N__h5 PAD_N__h17 624070
RNR1873 PAD_N__h5 PAD_N__h18 668043
RNR1874 PAD_N__h5 PAD_N__h19 706048
RNR1875 PAD_N__h5 PAD_N__h20 742915
RNR1876 PAD_N__h5 PAD_N__h21 788412
RNR1877 PAD_N__h5 PAD_N__h22 839027
RNR1878 PAD_N__h5 PAD_N__h23 879217
RNR1879 PAD_N__h5 PAD_N__h24 898914
RNR1880 PAD_N__h6 PAD_N__h7 2249.08
RNR1881 PAD_N__h6 PAD_N__h8 4989.5
RNR1882 PAD_N__h6 PAD_N__h9 12142
RNR1883 PAD_N__h6 PAD_N__h10 26700.3
RNR1884 PAD_N__h6 PAD_N__h11 56597.1
RNR1885 PAD_N__h6 PAD_N__h12 110015
RNR1886 PAD_N__h6 PAD_N__h13 170712
RNR1887 PAD_N__h6 PAD_N__h14 212430
RNR1888 PAD_N__h6 PAD_N__h15 243053
RNR1889 PAD_N__h6 PAD_N__h16 265644
RNR1890 PAD_N__h6 PAD_N__h17 285387
RNR1891 PAD_N__h6 PAD_N__h18 305496
RNR1892 PAD_N__h6 PAD_N__h19 322875
RNR1893 PAD_N__h6 PAD_N__h20 339735
RNR1894 PAD_N__h6 PAD_N__h21 360540
RNR1895 PAD_N__h6 PAD_N__h22 383687
RNR1896 PAD_N__h6 PAD_N__h23 402066
RNR1897 PAD_N__h6 PAD_N__h24 411073
RNR1898 PAD_N__h7 PAD_N__h8 2109.74
RNR1899 PAD_N__h7 PAD_N__h9 5144.02
RNR1900 PAD_N__h7 PAD_N__h10 11316.3
RNR1901 PAD_N__h7 PAD_N__h11 23990.4
RNR1902 PAD_N__h7 PAD_N__h12 46635.5
RNR1903 PAD_N__h7 PAD_N__h13 72367.3
RNR1904 PAD_N__h7 PAD_N__h14 90053.6
RNR1905 PAD_N__h7 PAD_N__h15 103036
RNR1906 PAD_N__h7 PAD_N__h16 112613
RNR1907 PAD_N__h7 PAD_N__h17 120983
RNR1908 PAD_N__h7 PAD_N__h18 129507
RNR1909 PAD_N__h7 PAD_N__h19 136875
RNR1910 PAD_N__h7 PAD_N__h20 144022
RNR1911 PAD_N__h7 PAD_N__h21 152842
RNR1912 PAD_N__h7 PAD_N__h22 162655
RNR1913 PAD_N__h7 PAD_N__h23 170446
RNR1914 PAD_N__h7 PAD_N__h24 174264
RNR1915 PAD_N__h8 PAD_N__h9 2339.86
RNR1916 PAD_N__h8 PAD_N__h10 5153.6
RNR1917 PAD_N__h8 PAD_N__h11 10929.4
RNR1918 PAD_N__h8 PAD_N__h12 21248.8
RNR1919 PAD_N__h8 PAD_N__h13 32976.2
RNR1920 PAD_N__h8 PAD_N__h14 41037.4
RNR1921 PAD_N__h8 PAD_N__h15 46954.5
RNR1922 PAD_N__h8 PAD_N__h16 51319.1
RNR1923 PAD_N__h8 PAD_N__h17 55133.3
RNR1924 PAD_N__h8 PAD_N__h18 59018.2
RNR1925 PAD_N__h8 PAD_N__h19 62375.7
RNR1926 PAD_N__h8 PAD_N__h20 65632.8
RNR1927 PAD_N__h8 PAD_N__h21 69652.2
RNR1928 PAD_N__h8 PAD_N__h22 74123.8
RNR1929 PAD_N__h8 PAD_N__h23 77674.4
RNR1930 PAD_N__h8 PAD_N__h24 79414.5
RNR1931 PAD_N__h9 PAD_N__h10 2522.98
RNR1932 PAD_N__h9 PAD_N__h11 5355.69
RNR1933 PAD_N__h9 PAD_N__h12 10416.4
RNR1934 PAD_N__h9 PAD_N__h13 16169.5
RNR1935 PAD_N__h9 PAD_N__h14 20124.8
RNR1936 PAD_N__h9 PAD_N__h15 23027.7
RNR1937 PAD_N__h9 PAD_N__h16 25168.7
RNR1938 PAD_N__h9 PAD_N__h17 27039.4
RNR1939 PAD_N__h9 PAD_N__h18 28944.8
RNR1940 PAD_N__h9 PAD_N__h19 30591.5
RNR1941 PAD_N__h9 PAD_N__h20 32188.9
RNR1942 PAD_N__h9 PAD_N__h21 34160.2
RNR1943 PAD_N__h9 PAD_N__h22 36353.2
RNR1944 PAD_N__h9 PAD_N__h23 38094.6
RNR1945 PAD_N__h9 PAD_N__h24 38948
RNR1946 PAD_N__h10 PAD_N__h11 2159.34
RNR1947 PAD_N__h10 PAD_N__h12 4209.25
RNR1948 PAD_N__h10 PAD_N__h13 6544.09
RNR1949 PAD_N__h10 PAD_N__h14 8151.16
RNR1950 PAD_N__h10 PAD_N__h15 9329.92
RNR1951 PAD_N__h10 PAD_N__h16 10198.4
RNR1952 PAD_N__h10 PAD_N__h17 10956.8
RNR1953 PAD_N__h10 PAD_N__h18 11729.1
RNR1954 PAD_N__h10 PAD_N__h19 12396.4
RNR1955 PAD_N__h10 PAD_N__h20 13043.7
RNR1956 PAD_N__h10 PAD_N__h21 13842.5
RNR1957 PAD_N__h10 PAD_N__h22 14731.2
RNR1958 PAD_N__h10 PAD_N__h23 15436.8
RNR1959 PAD_N__h10 PAD_N__h24 15782.6
RNR1960 PAD_N__h11 PAD_N__h12 1876.87
RNR1961 PAD_N__h11 PAD_N__h13 2933.87
RNR1962 PAD_N__h11 PAD_N__h14 3664.4
RNR1963 PAD_N__h11 PAD_N__h15 4199.09
RNR1964 PAD_N__h11 PAD_N__h16 4591.67
RNR1965 PAD_N__h11 PAD_N__h17 4933.75
RNR1966 PAD_N__h11 PAD_N__h18 5281.72
RNR1967 PAD_N__h11 PAD_N__h19 5582.29
RNR1968 PAD_N__h11 PAD_N__h20 5873.81
RNR1969 PAD_N__h11 PAD_N__h21 6233.53
RNR1970 PAD_N__h11 PAD_N__h22 6633.72
RNR1971 PAD_N__h11 PAD_N__h23 6951.48
RNR1972 PAD_N__h11 PAD_N__h24 7107.21
RNR1973 PAD_N__h12 PAD_N__h13 1370.48
RNR1974 PAD_N__h12 PAD_N__h14 1728.89
RNR1975 PAD_N__h12 PAD_N__h15 1989.44
RNR1976 PAD_N__h12 PAD_N__h16 2178.41
RNR1977 PAD_N__h12 PAD_N__h17 2341.78
RNR1978 PAD_N__h12 PAD_N__h18 2507.35
RNR1979 PAD_N__h12 PAD_N__h19 2650.16
RNR1980 PAD_N__h12 PAD_N__h20 2788.6
RNR1981 PAD_N__h12 PAD_N__h21 2959.4
RNR1982 PAD_N__h12 PAD_N__h22 3149.39
RNR1983 PAD_N__h12 PAD_N__h23 3300.25
RNR1984 PAD_N__h12 PAD_N__h24 3374.18
RNR1985 PAD_N__h13 PAD_N__h14 849.537
RNR1986 PAD_N__h13 PAD_N__h15 999.253
RNR1987 PAD_N__h13 PAD_N__h16 1102.19
RNR1988 PAD_N__h13 PAD_N__h17 1187.78
RNR1989 PAD_N__h13 PAD_N__h18 1272.89
RNR1990 PAD_N__h13 PAD_N__h19 1345.73
RNR1991 PAD_N__h13 PAD_N__h20 1416.15
RNR1992 PAD_N__h13 PAD_N__h21 1502.92
RNR1993 PAD_N__h13 PAD_N__h22 1599.41
RNR1994 PAD_N__h13 PAD_N__h23 1676.02
RNR1995 PAD_N__h13 PAD_N__h24 1713.56
RNR1996 PAD_N__h14 PAD_N__h15 624.638
RNR1997 PAD_N__h14 PAD_N__h16 703.718
RNR1998 PAD_N__h14 PAD_N__h17 763.902
RNR1999 PAD_N__h14 PAD_N__h18 820.809
RNR2000 PAD_N__h14 PAD_N__h19 868.436
RNR2001 PAD_N__h14 PAD_N__h20 914.11
RNR2002 PAD_N__h14 PAD_N__h21 970.185
RNR2003 PAD_N__h14 PAD_N__h22 1032.47
RNR2004 PAD_N__h14 PAD_N__h23 1081.93
RNR2005 PAD_N__h14 PAD_N__h24 1106.16
RNR2006 PAD_N__h15 PAD_N__h16 483.379
RNR2007 PAD_N__h15 PAD_N__h17 536.376
RNR2008 PAD_N__h15 PAD_N__h18 581.043
RNR2009 PAD_N__h15 PAD_N__h19 616.203
RNR2010 PAD_N__h15 PAD_N__h20 649.118
RNR2011 PAD_N__h15 PAD_N__h21 689.083
RNR2012 PAD_N__h15 PAD_N__h22 733.323
RNR2013 PAD_N__h15 PAD_N__h23 768.45
RNR2014 PAD_N__h15 PAD_N__h24 785.665
RNR2015 PAD_N__h16 PAD_N__h17 406.114
RNR2016 PAD_N__h16 PAD_N__h18 448.674
RNR2017 PAD_N__h16 PAD_N__h19 478.578
RNR2018 PAD_N__h16 PAD_N__h20 505.117
RNR2019 PAD_N__h16 PAD_N__h21 536.498
RNR2020 PAD_N__h16 PAD_N__h22 570.944
RNR2021 PAD_N__h16 PAD_N__h23 598.293
RNR2022 PAD_N__h16 PAD_N__h24 611.696
RNR2023 PAD_N__h17 PAD_N__h18 356.588
RNR2024 PAD_N__h17 PAD_N__h19 386.169
RNR2025 PAD_N__h17 PAD_N__h20 409.689
RNR2026 PAD_N__h17 PAD_N__h21 435.753
RNR2027 PAD_N__h17 PAD_N__h22 463.736
RNR2028 PAD_N__h17 PAD_N__h23 485.949
RNR2029 PAD_N__h17 PAD_N__h24 496.835
RNR2030 PAD_N__h18 PAD_N__h19 310.174
RNR2031 PAD_N__h18 PAD_N__h20 334.267
RNR2032 PAD_N__h18 PAD_N__h21 357.076
RNR2033 PAD_N__h18 PAD_N__h22 380.02
RNR2034 PAD_N__h18 PAD_N__h23 398.223
RNR2035 PAD_N__h18 PAD_N__h24 407.144
RNR2036 PAD_N__h19 PAD_N__h20 279.435
RNR2037 PAD_N__h19 PAD_N__h21 301.835
RNR2038 PAD_N__h19 PAD_N__h22 321.257
RNR2039 PAD_N__h19 PAD_N__h23 336.646
RNR2040 PAD_N__h19 PAD_N__h24 344.188
RNR2041 PAD_N__h20 PAD_N__h21 254.124
RNR2042 PAD_N__h20 PAD_N__h22 270.542
RNR2043 PAD_N__h20 PAD_N__h23 283.501
RNR2044 PAD_N__h20 PAD_N__h24 289.852
RNR2045 PAD_N__h21 PAD_N__h22 217.305
RNR2046 PAD_N__h21 PAD_N__h23 227.714
RNR2047 PAD_N__h21 PAD_N__h24 232.815
RNR2048 PAD_N__h22 PAD_N__h23 179.757
RNR2049 PAD_N__h22 PAD_N__h24 183.784
RNR2050 PAD_N__h23 PAD_N__h24 146.66
RNR2051 PAD_N__dn PAD_N__up 138.297
RNR2052 PAD_N__dn PAD_N__up 158.455
RNR2053 PAD_N__dn PAD_N__up 176.932
RNR2054 PAD_N__dn PAD_N__up 191.305
RNR2055 PAD_N__dn PAD_N__up 199.697
RNR2056 PAD_N__dn PAD_N__up 192.539
RNR2057 PAD_N__dn PAD_N__up 220.603
RNR2058 PAD_N__dn PAD_N__up 246.327
RNR2059 PAD_N__dn PAD_N__up 266.337
RNR2060 PAD_N__dn PAD_N__up 278.021
RNR2061 PAD_N__dn PAD_N__up 251.122
RNR2062 PAD_N__dn PAD_N__up 287.725
RNR2063 PAD_N__dn PAD_N__up 321.276
RNR2064 PAD_N__dn PAD_N__up 347.374
RNR2065 PAD_N__dn PAD_N__up 362.612
RNR2066 PAD_N__dn PAD_N__up 303.213
RNR2067 PAD_N__dn PAD_N__up 347.409
RNR2068 PAD_N__dn PAD_N__up 387.919
RNR2069 PAD_N__dn PAD_N__up 419.431
RNR2070 PAD_N__dn PAD_N__up 437.83
RNR2071 PAD_N__dn PAD_N__up 333.328
RNR2072 PAD_N__dn PAD_N__up 381.913
RNR2073 PAD_N__dn PAD_N__up 426.447
RNR2074 PAD_N__dn PAD_N__up 461.089
RNR2075 PAD_N__dn PAD_N__up 481.315
RNR2076 RX_N RX_N__mim 237.868
RNR2077 RX_N RX_N__dev 255.875
RNR2078 RX_N RX_N__dev 264.251
RNR2079 RX_N RX_N__dev 211.555
RNR2080 RX_N__mim RX_N__dev 162.615
RNR2081 RX_N__mim RX_N__dev 155.834
RNR2082 RX_N__mim RX_N__dev 144.852
RNR2083 VSS VSS__aP 0.778706
RNR2084 VSS VSS__aP 0.77232
RNR2085 VSS VSS__aP 0.771127
RNR2086 VSS VSS__aP 0.773472
RNR2087 VSS VSS__aP 0.780815
RNR2088 DVDD DVDD__kP 1.42589
RNR2089 DVDD DVDD__kP 1.41603
RNR2090 DVDD DVDD__kP 1.41449
RNR2091 DVDD DVDD__kP 1.41875
RNR2092 DVDD DVDD__kP 1.43424
RNR2093 VSS VSS__aN 0.778706
RNR2094 VSS VSS__aN 0.77232
RNR2095 VSS VSS__aN 0.771127
RNR2096 VSS VSS__aN 0.773472
RNR2097 VSS VSS__aN 0.780815
RNR2098 DVDD DVDD__kN 1.42589
RNR2099 DVDD DVDD__kN 1.41603
RNR2100 DVDD DVDD__kN 1.41449
RNR2101 DVDD DVDD__kN 1.41874
RNR2102 DVDD DVDD__kN 1.43424
RNR2103 DVDD DVDD__sP0 93.3878
RNR2104 DVDD DVDD__sP1 132.523
RNR2105 DVDD DVDD__sP2 108.781
RNR2106 DVDD DVDD__sP3 117.784
RNR2107 DVDD DVDD__sP4 129.506
RNR2108 DVDD DVDD__sP5 140.109
RNR2109 DVDD DVDD__sP6 151.399
RNR2110 DVDD DVDD__sP7 164.673
RNR2111 DVDD DVDD__sP8 177.527
RNR2112 DVDD DVDD__sP9 191.046
RNR2113 DVDD DVDD__sP10 205.173
RNR2114 DVDD DVDD__sP11 218.989
RNR2115 DVDD DVDD__sP12 234.79
RNR2116 DVDD DVDD__sP13 250.082
RNR2117 DVDD DVDD__sP14 267.804
RNR2118 DVDD DVDD__sP15 372.69
RNR2119 DVDD DVDD__sP16 298.183
RNR2120 DVDD DVDD__sP17 314.682
RNR2121 DVDD DVDD__sP18 431.509
RNR2122 DVDD DVDD__sP19 341.432
RNR2123 DVDD DVDD__sP20 355.258
RNR2124 DVDD DVDD__sP21 365.371
RNR2125 DVDD DVDD__sP22 372.471
RNR2126 DVDD DVDD__sP23 378.962
RNR2127 DVDD DVDD__sP24 382.456
RNR2128 DVDD DVDD__sN0 128.464
RNR2129 DVDD DVDD__sN1 182.298
RNR2130 DVDD DVDD__sN2 149.639
RNR2131 DVDD DVDD__sN3 162.024
RNR2132 DVDD DVDD__sN4 178.148
RNR2133 DVDD DVDD__sN5 192.733
RNR2134 DVDD DVDD__sN6 208.263
RNR2135 DVDD DVDD__sN7 226.524
RNR2136 DVDD DVDD__sN8 244.206
RNR2137 DVDD DVDD__sN9 262.803
RNR2138 DVDD DVDD__sN10 282.236
RNR2139 DVDD DVDD__sN11 301.241
RNR2140 DVDD DVDD__sN12 322.977
RNR2141 DVDD DVDD__sN13 344.012
RNR2142 DVDD DVDD__sN14 368.39
RNR2143 DVDD DVDD__sN15 512.672
RNR2144 DVDD DVDD__sN16 410.179
RNR2145 DVDD DVDD__sN17 432.876
RNR2146 DVDD DVDD__sN18 593.583
RNR2147 DVDD DVDD__sN19 469.673
RNR2148 DVDD DVDD__sN20 488.692
RNR2149 DVDD DVDD__sN21 502.603
RNR2150 DVDD DVDD__sN22 512.37
RNR2151 DVDD DVDD__sN23 521.299
RNR2152 DVDD DVDD__sN24 526.106
RNR2153 DVDD__sP0 DVDD__sP1 606.986
RNR2154 DVDD__sP0 DVDD__sP2 498.247
RNR2155 DVDD__sP0 DVDD__sP3 539.481
RNR2156 DVDD__sP0 DVDD__sP4 593.171
RNR2157 DVDD__sP0 DVDD__sP5 641.733
RNR2158 DVDD__sP0 DVDD__sP6 693.444
RNR2159 DVDD__sP0 DVDD__sP7 754.243
RNR2160 DVDD__sP0 DVDD__sP8 813.12
RNR2161 DVDD__sP0 DVDD__sP9 875.041
RNR2162 DVDD__sP0 DVDD__sP10 939.746
RNR2163 DVDD__sP0 DVDD__sP11 1003.03
RNR2164 DVDD__sP0 DVDD__sP12 1075.4
RNR2165 DVDD__sP0 DVDD__sP13 1145.44
RNR2166 DVDD__sP0 DVDD__sP14 1226.61
RNR2167 DVDD__sP0 DVDD__sP15 1707.02
RNR2168 DVDD__sP0 DVDD__sP16 1365.75
RNR2169 DVDD__sP0 DVDD__sP17 1441.32
RNR2170 DVDD__sP0 DVDD__sP18 1976.42
RNR2171 DVDD__sP0 DVDD__sP19 1563.84
RNR2172 DVDD__sP0 DVDD__sP20 1627.17
RNR2173 DVDD__sP0 DVDD__sP21 1673.49
RNR2174 DVDD__sP0 DVDD__sP22 1706.01
RNR2175 DVDD__sP0 DVDD__sP23 1735.74
RNR2176 DVDD__sP0 DVDD__sP24 1751.75
RNR2177 DVDD__sP0 DVDD__sN0 2590.92
RNR2178 DVDD__sP0 DVDD__sN1 3676.67
RNR2179 DVDD__sP0 DVDD__sN2 3018
RNR2180 DVDD__sP0 DVDD__sN3 3267.77
RNR2181 DVDD__sP0 DVDD__sN4 3592.98
RNR2182 DVDD__sP0 DVDD__sN5 3887.13
RNR2183 DVDD__sP0 DVDD__sN6 4200.36
RNR2184 DVDD__sP0 DVDD__sN7 4568.63
RNR2185 DVDD__sP0 DVDD__sN8 4925.27
RNR2186 DVDD__sP0 DVDD__sN9 5300.33
RNR2187 DVDD__sP0 DVDD__sN10 5692.27
RNR2188 DVDD__sP0 DVDD__sN11 6075.57
RNR2189 DVDD__sP0 DVDD__sN12 6513.95
RNR2190 DVDD__sP0 DVDD__sN13 6938.19
RNR2191 DVDD__sP0 DVDD__sN14 7429.86
RNR2192 DVDD__sP0 DVDD__sN15 10339.8
RNR2193 DVDD__sP0 DVDD__sN16 8272.69
RNR2194 DVDD__sP0 DVDD__sN17 8730.44
RNR2195 DVDD__sP0 DVDD__sN18 11971.7
RNR2196 DVDD__sP0 DVDD__sN19 9472.58
RNR2197 DVDD__sP0 DVDD__sN20 9856.18
RNR2198 DVDD__sP0 DVDD__sN21 10136.7
RNR2199 DVDD__sP0 DVDD__sN22 10333.7
RNR2200 DVDD__sP0 DVDD__sN23 10513.8
RNR2201 DVDD__sP0 DVDD__sN24 10610.7
RNR2202 DVDD__sP1 DVDD__sP2 622.935
RNR2203 DVDD__sP1 DVDD__sP3 674.49
RNR2204 DVDD__sP1 DVDD__sP4 741.616
RNR2205 DVDD__sP1 DVDD__sP5 802.331
RNR2206 DVDD__sP1 DVDD__sP6 866.982
RNR2207 DVDD__sP1 DVDD__sP7 942.998
RNR2208 DVDD__sP1 DVDD__sP8 1016.61
RNR2209 DVDD__sP1 DVDD__sP9 1094.03
RNR2210 DVDD__sP1 DVDD__sP10 1174.92
RNR2211 DVDD__sP1 DVDD__sP11 1254.04
RNR2212 DVDD__sP1 DVDD__sP12 1344.53
RNR2213 DVDD__sP1 DVDD__sP13 1432.09
RNR2214 DVDD__sP1 DVDD__sP14 1533.58
RNR2215 DVDD__sP1 DVDD__sP15 2134.21
RNR2216 DVDD__sP1 DVDD__sP16 1707.54
RNR2217 DVDD__sP1 DVDD__sP17 1802.02
RNR2218 DVDD__sP1 DVDD__sP18 2471.03
RNR2219 DVDD__sP1 DVDD__sP19 1955.21
RNR2220 DVDD__sP1 DVDD__sP20 2034.38
RNR2221 DVDD__sP1 DVDD__sP21 2092.29
RNR2222 DVDD__sP1 DVDD__sP22 2132.95
RNR2223 DVDD__sP1 DVDD__sP23 2170.12
RNR2224 DVDD__sP1 DVDD__sP24 2190.13
RNR2225 DVDD__sP1 DVDD__sN0 3676.67
RNR2226 DVDD__sP1 DVDD__sN1 5217.39
RNR2227 DVDD__sP1 DVDD__sN2 4282.71
RNR2228 DVDD__sP1 DVDD__sN3 4637.15
RNR2229 DVDD__sP1 DVDD__sN4 5098.64
RNR2230 DVDD__sP1 DVDD__sN5 5516.06
RNR2231 DVDD__sP1 DVDD__sN6 5960.54
RNR2232 DVDD__sP1 DVDD__sN7 6483.15
RNR2233 DVDD__sP1 DVDD__sN8 6989.23
RNR2234 DVDD__sP1 DVDD__sN9 7521.47
RNR2235 DVDD__sP1 DVDD__sN10 8077.64
RNR2236 DVDD__sP1 DVDD__sN11 8621.57
RNR2237 DVDD__sP1 DVDD__sN12 9243.66
RNR2238 DVDD__sP1 DVDD__sN13 9845.67
RNR2239 DVDD__sP1 DVDD__sN14 10543.4
RNR2240 DVDD__sP1 DVDD__sN15 14672.8
RNR2241 DVDD__sP1 DVDD__sN16 11739.4
RNR2242 DVDD__sP1 DVDD__sN17 12389
RNR2243 DVDD__sP1 DVDD__sN18 16988.5
RNR2244 DVDD__sP1 DVDD__sN19 13442.1
RNR2245 DVDD__sP1 DVDD__sN20 13986.5
RNR2246 DVDD__sP1 DVDD__sN21 14384.6
RNR2247 DVDD__sP1 DVDD__sN22 14664.1
RNR2248 DVDD__sP1 DVDD__sN23 14919.7
RNR2249 DVDD__sP1 DVDD__sN24 15057.2
RNR2250 DVDD__sP2 DVDD__sP3 486.278
RNR2251 DVDD__sP2 DVDD__sP4 534.673
RNR2252 DVDD__sP2 DVDD__sP5 578.446
RNR2253 DVDD__sP2 DVDD__sP6 625.057
RNR2254 DVDD__sP2 DVDD__sP7 679.861
RNR2255 DVDD__sP2 DVDD__sP8 732.931
RNR2256 DVDD__sP2 DVDD__sP9 788.745
RNR2257 DVDD__sP2 DVDD__sP10 847.069
RNR2258 DVDD__sP2 DVDD__sP11 904.109
RNR2259 DVDD__sP2 DVDD__sP12 969.345
RNR2260 DVDD__sP2 DVDD__sP13 1032.48
RNR2261 DVDD__sP2 DVDD__sP14 1105.64
RNR2262 DVDD__sP2 DVDD__sP15 1538.67
RNR2263 DVDD__sP2 DVDD__sP16 1231.06
RNR2264 DVDD__sP2 DVDD__sP17 1299.18
RNR2265 DVDD__sP2 DVDD__sP18 1781.51
RNR2266 DVDD__sP2 DVDD__sP19 1409.62
RNR2267 DVDD__sP2 DVDD__sP20 1466.7
RNR2268 DVDD__sP2 DVDD__sP21 1508.45
RNR2269 DVDD__sP2 DVDD__sP22 1537.77
RNR2270 DVDD__sP2 DVDD__sP23 1564.57
RNR2271 DVDD__sP2 DVDD__sP24 1578.99
RNR2272 DVDD__sP2 DVDD__sN0 3018
RNR2273 DVDD__sP2 DVDD__sN1 4282.71
RNR2274 DVDD__sP2 DVDD__sN2 3515.47
RNR2275 DVDD__sP2 DVDD__sN3 3806.41
RNR2276 DVDD__sP2 DVDD__sN4 4185.23
RNR2277 DVDD__sP2 DVDD__sN5 4527.87
RNR2278 DVDD__sP2 DVDD__sN6 4892.72
RNR2279 DVDD__sP2 DVDD__sN7 5321.71
RNR2280 DVDD__sP2 DVDD__sN8 5737.12
RNR2281 DVDD__sP2 DVDD__sN9 6174.02
RNR2282 DVDD__sP2 DVDD__sN10 6630.55
RNR2283 DVDD__sP2 DVDD__sN11 7077.04
RNR2284 DVDD__sP2 DVDD__sN12 7587.68
RNR2285 DVDD__sP2 DVDD__sN13 8081.84
RNR2286 DVDD__sP2 DVDD__sN14 8654.57
RNR2287 DVDD__sP2 DVDD__sN15 12044.2
RNR2288 DVDD__sP2 DVDD__sN16 9636.32
RNR2289 DVDD__sP2 DVDD__sN17 10169.5
RNR2290 DVDD__sP2 DVDD__sN18 13945
RNR2291 DVDD__sP2 DVDD__sN19 11034
RNR2292 DVDD__sP2 DVDD__sN20 11480.8
RNR2293 DVDD__sP2 DVDD__sN21 11807.6
RNR2294 DVDD__sP2 DVDD__sN22 12037.1
RNR2295 DVDD__sP2 DVDD__sN23 12246.9
RNR2296 DVDD__sP2 DVDD__sN24 12359.8
RNR2297 DVDD__sP3 DVDD__sP4 503.545
RNR2298 DVDD__sP3 DVDD__sP5 544.77
RNR2299 DVDD__sP3 DVDD__sP6 588.668
RNR2300 DVDD__sP3 DVDD__sP7 640.281
RNR2301 DVDD__sP3 DVDD__sP8 690.262
RNR2302 DVDD__sP3 DVDD__sP9 742.826
RNR2303 DVDD__sP3 DVDD__sP10 797.755
RNR2304 DVDD__sP3 DVDD__sP11 851.473
RNR2305 DVDD__sP3 DVDD__sP12 912.912
RNR2306 DVDD__sP3 DVDD__sP13 972.367
RNR2307 DVDD__sP3 DVDD__sP14 1041.27
RNR2308 DVDD__sP3 DVDD__sP15 1449.09
RNR2309 DVDD__sP3 DVDD__sP16 1159.39
RNR2310 DVDD__sP3 DVDD__sP17 1223.55
RNR2311 DVDD__sP3 DVDD__sP18 1677.79
RNR2312 DVDD__sP3 DVDD__sP19 1327.55
RNR2313 DVDD__sP3 DVDD__sP20 1381.31
RNR2314 DVDD__sP3 DVDD__sP21 1420.63
RNR2315 DVDD__sP3 DVDD__sP22 1448.24
RNR2316 DVDD__sP3 DVDD__sP23 1473.48
RNR2317 DVDD__sP3 DVDD__sP24 1487.07
RNR2318 DVDD__sP3 DVDD__sN0 3267.77
RNR2319 DVDD__sP3 DVDD__sN1 4637.15
RNR2320 DVDD__sP3 DVDD__sN2 3806.41
RNR2321 DVDD__sP3 DVDD__sN3 4121.43
RNR2322 DVDD__sP3 DVDD__sN4 4531.6
RNR2323 DVDD__sP3 DVDD__sN5 4902.59
RNR2324 DVDD__sP3 DVDD__sN6 5297.64
RNR2325 DVDD__sP3 DVDD__sN7 5762.13
RNR2326 DVDD__sP3 DVDD__sN8 6211.93
RNR2327 DVDD__sP3 DVDD__sN9 6684.97
RNR2328 DVDD__sP3 DVDD__sN10 7179.3
RNR2329 DVDD__sP3 DVDD__sN11 7662.73
RNR2330 DVDD__sP3 DVDD__sN12 8215.64
RNR2331 DVDD__sP3 DVDD__sN13 8750.7
RNR2332 DVDD__sP3 DVDD__sN14 9370.82
RNR2333 DVDD__sP3 DVDD__sN15 13040.9
RNR2334 DVDD__sP3 DVDD__sN16 10433.8
RNR2335 DVDD__sP3 DVDD__sN17 11011.1
RNR2336 DVDD__sP3 DVDD__sN18 15099.1
RNR2337 DVDD__sP3 DVDD__sN19 11947.2
RNR2338 DVDD__sP3 DVDD__sN20 12431
RNR2339 DVDD__sP3 DVDD__sN21 12784.8
RNR2340 DVDD__sP3 DVDD__sN22 13033.3
RNR2341 DVDD__sP3 DVDD__sN23 13260.4
RNR2342 DVDD__sP3 DVDD__sN24 13382.7
RNR2343 DVDD__sP4 DVDD__sP5 505.079
RNR2344 DVDD__sP4 DVDD__sP6 545.778
RNR2345 DVDD__sP4 DVDD__sP7 593.631
RNR2346 DVDD__sP4 DVDD__sP8 639.971
RNR2347 DVDD__sP4 DVDD__sP9 688.705
RNR2348 DVDD__sP4 DVDD__sP10 739.632
RNR2349 DVDD__sP4 DVDD__sP11 789.437
RNR2350 DVDD__sP4 DVDD__sP12 846.399
RNR2351 DVDD__sP4 DVDD__sP13 901.522
RNR2352 DVDD__sP4 DVDD__sP14 965.409
RNR2353 DVDD__sP4 DVDD__sP15 1343.52
RNR2354 DVDD__sP4 DVDD__sP16 1074.92
RNR2355 DVDD__sP4 DVDD__sP17 1134.4
RNR2356 DVDD__sP4 DVDD__sP18 1555.55
RNR2357 DVDD__sP4 DVDD__sP19 1230.83
RNR2358 DVDD__sP4 DVDD__sP20 1280.67
RNR2359 DVDD__sP4 DVDD__sP21 1317.13
RNR2360 DVDD__sP4 DVDD__sP22 1342.73
RNR2361 DVDD__sP4 DVDD__sP23 1366.13
RNR2362 DVDD__sP4 DVDD__sP24 1378.72
RNR2363 DVDD__sP4 DVDD__sN0 3592.98
RNR2364 DVDD__sP4 DVDD__sN1 5098.64
RNR2365 DVDD__sP4 DVDD__sN2 4185.23
RNR2366 DVDD__sP4 DVDD__sN3 4531.6
RNR2367 DVDD__sP4 DVDD__sN4 4982.58
RNR2368 DVDD__sP4 DVDD__sN5 5390.5
RNR2369 DVDD__sP4 DVDD__sN6 5824.87
RNR2370 DVDD__sP4 DVDD__sN7 6335.58
RNR2371 DVDD__sP4 DVDD__sN8 6830.14
RNR2372 DVDD__sP4 DVDD__sN9 7350.27
RNR2373 DVDD__sP4 DVDD__sN10 7893.78
RNR2374 DVDD__sP4 DVDD__sN11 8425.33
RNR2375 DVDD__sP4 DVDD__sN12 9033.26
RNR2376 DVDD__sP4 DVDD__sN13 9621.57
RNR2377 DVDD__sP4 DVDD__sN14 10303.4
RNR2378 DVDD__sP4 DVDD__sN15 14338.8
RNR2379 DVDD__sP4 DVDD__sN16 11472.2
RNR2380 DVDD__sP4 DVDD__sN17 12107
RNR2381 DVDD__sP4 DVDD__sN18 16601.8
RNR2382 DVDD__sP4 DVDD__sN19 13136.1
RNR2383 DVDD__sP4 DVDD__sN20 13668.1
RNR2384 DVDD__sP4 DVDD__sN21 14057.2
RNR2385 DVDD__sP4 DVDD__sN22 14330.3
RNR2386 DVDD__sP4 DVDD__sN23 14580.1
RNR2387 DVDD__sP4 DVDD__sN24 14714.5
RNR2388 DVDD__sP5 DVDD__sP6 511.008
RNR2389 DVDD__sP5 DVDD__sP7 555.813
RNR2390 DVDD__sP5 DVDD__sP8 599.201
RNR2391 DVDD__sP5 DVDD__sP9 644.831
RNR2392 DVDD__sP5 DVDD__sP10 692.513
RNR2393 DVDD__sP5 DVDD__sP11 739.145
RNR2394 DVDD__sP5 DVDD__sP12 792.478
RNR2395 DVDD__sP5 DVDD__sP13 844.089
RNR2396 DVDD__sP5 DVDD__sP14 903.906
RNR2397 DVDD__sP5 DVDD__sP15 1257.93
RNR2398 DVDD__sP5 DVDD__sP16 1006.44
RNR2399 DVDD__sP5 DVDD__sP17 1062.13
RNR2400 DVDD__sP5 DVDD__sP18 1456.45
RNR2401 DVDD__sP5 DVDD__sP19 1152.42
RNR2402 DVDD__sP5 DVDD__sP20 1199.09
RNR2403 DVDD__sP5 DVDD__sP21 1233.22
RNR2404 DVDD__sP5 DVDD__sP22 1257.19
RNR2405 DVDD__sP5 DVDD__sP23 1279.09
RNR2406 DVDD__sP5 DVDD__sP24 1290.89
RNR2407 DVDD__sP5 DVDD__sN0 3887.13
RNR2408 DVDD__sP5 DVDD__sN1 5516.06
RNR2409 DVDD__sP5 DVDD__sN2 4527.87
RNR2410 DVDD__sP5 DVDD__sN3 4902.59
RNR2411 DVDD__sP5 DVDD__sN4 5390.5
RNR2412 DVDD__sP5 DVDD__sN5 5831.82
RNR2413 DVDD__sP5 DVDD__sN6 6301.74
RNR2414 DVDD__sP5 DVDD__sN7 6854.27
RNR2415 DVDD__sP5 DVDD__sN8 7389.32
RNR2416 DVDD__sP5 DVDD__sN9 7952.03
RNR2417 DVDD__sP5 DVDD__sN10 8540.04
RNR2418 DVDD__sP5 DVDD__sN11 9115.1
RNR2419 DVDD__sP5 DVDD__sN12 9772.8
RNR2420 DVDD__sP5 DVDD__sN13 10409.3
RNR2421 DVDD__sP5 DVDD__sN14 11146.9
RNR2422 DVDD__sP5 DVDD__sN15 15512.7
RNR2423 DVDD__sP5 DVDD__sN16 12411.4
RNR2424 DVDD__sP5 DVDD__sN17 13098.2
RNR2425 DVDD__sP5 DVDD__sN18 17960.9
RNR2426 DVDD__sP5 DVDD__sN19 14211.6
RNR2427 DVDD__sP5 DVDD__sN20 14787.1
RNR2428 DVDD__sP5 DVDD__sN21 15208
RNR2429 DVDD__sP5 DVDD__sN22 15503.6
RNR2430 DVDD__sP5 DVDD__sN23 15773.7
RNR2431 DVDD__sP5 DVDD__sN24 15919.2
RNR2432 DVDD__sP6 DVDD__sP7 518.964
RNR2433 DVDD__sP6 DVDD__sP8 559.475
RNR2434 DVDD__sP6 DVDD__sP9 602.08
RNR2435 DVDD__sP6 DVDD__sP10 646.601
RNR2436 DVDD__sP6 DVDD__sP11 690.142
RNR2437 DVDD__sP6 DVDD__sP12 739.939
RNR2438 DVDD__sP6 DVDD__sP13 788.129
RNR2439 DVDD__sP6 DVDD__sP14 843.98
RNR2440 DVDD__sP6 DVDD__sP15 1174.53
RNR2441 DVDD__sP6 DVDD__sP16 939.719
RNR2442 DVDD__sP6 DVDD__sP17 991.716
RNR2443 DVDD__sP6 DVDD__sP18 1359.9
RNR2444 DVDD__sP6 DVDD__sP19 1076.02
RNR2445 DVDD__sP6 DVDD__sP20 1119.59
RNR2446 DVDD__sP6 DVDD__sP21 1151.46
RNR2447 DVDD__sP6 DVDD__sP22 1173.84
RNR2448 DVDD__sP6 DVDD__sP23 1194.29
RNR2449 DVDD__sP6 DVDD__sP24 1205.31
RNR2450 DVDD__sP6 DVDD__sN0 4200.36
RNR2451 DVDD__sP6 DVDD__sN1 5960.54
RNR2452 DVDD__sP6 DVDD__sN2 4892.72
RNR2453 DVDD__sP6 DVDD__sN3 5297.64
RNR2454 DVDD__sP6 DVDD__sN4 5824.87
RNR2455 DVDD__sP6 DVDD__sN5 6301.74
RNR2456 DVDD__sP6 DVDD__sN6 6809.53
RNR2457 DVDD__sP6 DVDD__sN7 7406.58
RNR2458 DVDD__sP6 DVDD__sN8 7984.75
RNR2459 DVDD__sP6 DVDD__sN9 8592.8
RNR2460 DVDD__sP6 DVDD__sN10 9228.19
RNR2461 DVDD__sP6 DVDD__sN11 9849.59
RNR2462 DVDD__sP6 DVDD__sN12 10560.3
RNR2463 DVDD__sP6 DVDD__sN13 11248.1
RNR2464 DVDD__sP6 DVDD__sN14 12045.1
RNR2465 DVDD__sP6 DVDD__sN15 16762.7
RNR2466 DVDD__sP6 DVDD__sN16 13411.5
RNR2467 DVDD__sP6 DVDD__sN17 14153.6
RNR2468 DVDD__sP6 DVDD__sN18 19408.2
RNR2469 DVDD__sP6 DVDD__sN19 15356.8
RNR2470 DVDD__sP6 DVDD__sN20 15978.6
RNR2471 DVDD__sP6 DVDD__sN21 16433.5
RNR2472 DVDD__sP6 DVDD__sN22 16752.8
RNR2473 DVDD__sP6 DVDD__sN23 17044.8
RNR2474 DVDD__sP6 DVDD__sN24 17201.9
RNR2475 DVDD__sP7 DVDD__sP8 517.575
RNR2476 DVDD__sP7 DVDD__sP9 556.989
RNR2477 DVDD__sP7 DVDD__sP10 598.176
RNR2478 DVDD__sP7 DVDD__sP11 638.456
RNR2479 DVDD__sP7 DVDD__sP12 684.524
RNR2480 DVDD__sP7 DVDD__sP13 729.104
RNR2481 DVDD__sP7 DVDD__sP14 780.773
RNR2482 DVDD__sP7 DVDD__sP15 1086.57
RNR2483 DVDD__sP7 DVDD__sP16 869.342
RNR2484 DVDD__sP7 DVDD__sP17 917.444
RNR2485 DVDD__sP7 DVDD__sP18 1258.05
RNR2486 DVDD__sP7 DVDD__sP19 995.433
RNR2487 DVDD__sP7 DVDD__sP20 1035.74
RNR2488 DVDD__sP7 DVDD__sP21 1065.23
RNR2489 DVDD__sP7 DVDD__sP22 1085.93
RNR2490 DVDD__sP7 DVDD__sP23 1104.85
RNR2491 DVDD__sP7 DVDD__sP24 1115.04
RNR2492 DVDD__sP7 DVDD__sN0 4568.63
RNR2493 DVDD__sP7 DVDD__sN1 6483.15
RNR2494 DVDD__sP7 DVDD__sN2 5321.71
RNR2495 DVDD__sP7 DVDD__sN3 5762.13
RNR2496 DVDD__sP7 DVDD__sN4 6335.58
RNR2497 DVDD__sP7 DVDD__sN5 6854.27
RNR2498 DVDD__sP7 DVDD__sN6 7406.58
RNR2499 DVDD__sP7 DVDD__sN7 8055.97
RNR2500 DVDD__sP7 DVDD__sN8 8684.83
RNR2501 DVDD__sP7 DVDD__sN9 9346.2
RNR2502 DVDD__sP7 DVDD__sN10 10037.3
RNR2503 DVDD__sP7 DVDD__sN11 10713.2
RNR2504 DVDD__sP7 DVDD__sN12 11486.2
RNR2505 DVDD__sP7 DVDD__sN13 12234.3
RNR2506 DVDD__sP7 DVDD__sN14 13101.2
RNR2507 DVDD__sP7 DVDD__sN15 18232.4
RNR2508 DVDD__sP7 DVDD__sN16 14587.4
RNR2509 DVDD__sP7 DVDD__sN17 15394.6
RNR2510 DVDD__sP7 DVDD__sN18 21109.9
RNR2511 DVDD__sP7 DVDD__sN19 16703.2
RNR2512 DVDD__sP7 DVDD__sN20 17379.6
RNR2513 DVDD__sP7 DVDD__sN21 17874.3
RNR2514 DVDD__sP7 DVDD__sN22 18221.7
RNR2515 DVDD__sP7 DVDD__sN23 18539.2
RNR2516 DVDD__sP7 DVDD__sN24 18710.2
RNR2517 DVDD__sP8 DVDD__sP9 517.945
RNR2518 DVDD__sP8 DVDD__sP10 556.245
RNR2519 DVDD__sP8 DVDD__sP11 593.702
RNR2520 DVDD__sP8 DVDD__sP12 636.54
RNR2521 DVDD__sP8 DVDD__sP13 677.996
RNR2522 DVDD__sP8 DVDD__sP14 726.043
RNR2523 DVDD__sP8 DVDD__sP15 1010.4
RNR2524 DVDD__sP8 DVDD__sP16 808.403
RNR2525 DVDD__sP8 DVDD__sP17 853.134
RNR2526 DVDD__sP8 DVDD__sP18 1169.86
RNR2527 DVDD__sP8 DVDD__sP19 925.656
RNR2528 DVDD__sP8 DVDD__sP20 963.141
RNR2529 DVDD__sP8 DVDD__sP21 990.557
RNR2530 DVDD__sP8 DVDD__sP22 1009.81
RNR2531 DVDD__sP8 DVDD__sP23 1027.4
RNR2532 DVDD__sP8 DVDD__sP24 1036.88
RNR2533 DVDD__sP8 DVDD__sN0 4925.27
RNR2534 DVDD__sP8 DVDD__sN1 6989.23
RNR2535 DVDD__sP8 DVDD__sN2 5737.12
RNR2536 DVDD__sP8 DVDD__sN3 6211.93
RNR2537 DVDD__sP8 DVDD__sN4 6830.14
RNR2538 DVDD__sP8 DVDD__sN5 7389.32
RNR2539 DVDD__sP8 DVDD__sN6 7984.75
RNR2540 DVDD__sP8 DVDD__sN7 8684.83
RNR2541 DVDD__sP8 DVDD__sN8 9362.78
RNR2542 DVDD__sP8 DVDD__sN9 10075.8
RNR2543 DVDD__sP8 DVDD__sN10 10820.8
RNR2544 DVDD__sP8 DVDD__sN11 11549.5
RNR2545 DVDD__sP8 DVDD__sN12 12382.8
RNR2546 DVDD__sP8 DVDD__sN13 13189.3
RNR2547 DVDD__sP8 DVDD__sN14 14123.9
RNR2548 DVDD__sP8 DVDD__sN15 19655.6
RNR2549 DVDD__sP8 DVDD__sN16 15726.1
RNR2550 DVDD__sP8 DVDD__sN17 16596.3
RNR2551 DVDD__sP8 DVDD__sN18 22757.7
RNR2552 DVDD__sP8 DVDD__sN19 18007.1
RNR2553 DVDD__sP8 DVDD__sN20 18736.3
RNR2554 DVDD__sP8 DVDD__sN21 19269.6
RNR2555 DVDD__sP8 DVDD__sN22 19644.1
RNR2556 DVDD__sP8 DVDD__sN23 19986.4
RNR2557 DVDD__sP8 DVDD__sN24 20170.7
RNR2558 DVDD__sP9 DVDD__sP10 516.287
RNR2559 DVDD__sP9 DVDD__sP11 551.053
RNR2560 DVDD__sP9 DVDD__sP12 590.814
RNR2561 DVDD__sP9 DVDD__sP13 629.292
RNR2562 DVDD__sP9 DVDD__sP14 673.887
RNR2563 DVDD__sP9 DVDD__sP15 937.818
RNR2564 DVDD__sP9 DVDD__sP16 750.331
RNR2565 DVDD__sP9 DVDD__sP17 791.849
RNR2566 DVDD__sP9 DVDD__sP18 1085.83
RNR2567 DVDD__sP9 DVDD__sP19 859.16
RNR2568 DVDD__sP9 DVDD__sP20 893.953
RNR2569 DVDD__sP9 DVDD__sP21 919.4
RNR2570 DVDD__sP9 DVDD__sP22 937.266
RNR2571 DVDD__sP9 DVDD__sP23 953.6
RNR2572 DVDD__sP9 DVDD__sP24 962.392
RNR2573 DVDD__sP9 DVDD__sN0 5300.33
RNR2574 DVDD__sP9 DVDD__sN1 7521.47
RNR2575 DVDD__sP9 DVDD__sN2 6174.02
RNR2576 DVDD__sP9 DVDD__sN3 6684.97
RNR2577 DVDD__sP9 DVDD__sN4 7350.27
RNR2578 DVDD__sP9 DVDD__sN5 7952.03
RNR2579 DVDD__sP9 DVDD__sN6 8592.8
RNR2580 DVDD__sP9 DVDD__sN7 9346.2
RNR2581 DVDD__sP9 DVDD__sN8 10075.8
RNR2582 DVDD__sP9 DVDD__sN9 10843.1
RNR2583 DVDD__sP9 DVDD__sN10 11644.8
RNR2584 DVDD__sP9 DVDD__sN11 12429
RNR2585 DVDD__sP9 DVDD__sN12 13325.8
RNR2586 DVDD__sP9 DVDD__sN13 14193.7
RNR2587 DVDD__sP9 DVDD__sN14 15199.5
RNR2588 DVDD__sP9 DVDD__sN15 21152.5
RNR2589 DVDD__sP9 DVDD__sN16 16923.7
RNR2590 DVDD__sP9 DVDD__sN17 17860.1
RNR2591 DVDD__sP9 DVDD__sN18 24490.8
RNR2592 DVDD__sP9 DVDD__sN19 19378.3
RNR2593 DVDD__sP9 DVDD__sN20 20163.1
RNR2594 DVDD__sP9 DVDD__sN21 20737
RNR2595 DVDD__sP9 DVDD__sN22 21140
RNR2596 DVDD__sP9 DVDD__sN23 21508.4
RNR2597 DVDD__sP9 DVDD__sN24 21706.7
RNR2598 DVDD__sP10 DVDD__sP11 510.642
RNR2599 DVDD__sP10 DVDD__sP12 547.489
RNR2600 DVDD__sP10 DVDD__sP13 583.145
RNR2601 DVDD__sP10 DVDD__sP14 624.47
RNR2602 DVDD__sP10 DVDD__sP15 869.047
RNR2603 DVDD__sP10 DVDD__sP16 695.309
RNR2604 DVDD__sP10 DVDD__sP17 733.782
RNR2605 DVDD__sP10 DVDD__sP18 1006.2
RNR2606 DVDD__sP10 DVDD__sP19 796.158
RNR2607 DVDD__sP10 DVDD__sP20 828.399
RNR2608 DVDD__sP10 DVDD__sP21 851.979
RNR2609 DVDD__sP10 DVDD__sP22 868.536
RNR2610 DVDD__sP10 DVDD__sP23 883.672
RNR2611 DVDD__sP10 DVDD__sP24 891.819
RNR2612 DVDD__sP10 DVDD__sN0 5692.27
RNR2613 DVDD__sP10 DVDD__sN1 8077.64
RNR2614 DVDD__sP10 DVDD__sN2 6630.55
RNR2615 DVDD__sP10 DVDD__sN3 7179.3
RNR2616 DVDD__sP10 DVDD__sN4 7893.78
RNR2617 DVDD__sP10 DVDD__sN5 8540.04
RNR2618 DVDD__sP10 DVDD__sN6 9228.19
RNR2619 DVDD__sP10 DVDD__sN7 10037.3
RNR2620 DVDD__sP10 DVDD__sN8 10820.8
RNR2621 DVDD__sP10 DVDD__sN9 11644.8
RNR2622 DVDD__sP10 DVDD__sN10 12505.9
RNR2623 DVDD__sP10 DVDD__sN11 13348
RNR2624 DVDD__sP10 DVDD__sN12 14311.2
RNR2625 DVDD__sP10 DVDD__sN13 15243.2
RNR2626 DVDD__sP10 DVDD__sN14 16323.4
RNR2627 DVDD__sP10 DVDD__sN15 22716.6
RNR2628 DVDD__sP10 DVDD__sN16 18175.1
RNR2629 DVDD__sP10 DVDD__sN17 19180.8
RNR2630 DVDD__sP10 DVDD__sN18 26301.8
RNR2631 DVDD__sP10 DVDD__sN19 20811.3
RNR2632 DVDD__sP10 DVDD__sN20 21654
RNR2633 DVDD__sP10 DVDD__sN21 22270.4
RNR2634 DVDD__sP10 DVDD__sN22 22703.2
RNR2635 DVDD__sP10 DVDD__sN23 23098.9
RNR2636 DVDD__sP10 DVDD__sN24 23311.8
RNR2637 DVDD__sP11 DVDD__sP12 508.358
RNR2638 DVDD__sP11 DVDD__sP13 541.466
RNR2639 DVDD__sP11 DVDD__sP14 579.838
RNR2640 DVDD__sP11 DVDD__sP15 806.934
RNR2641 DVDD__sP11 DVDD__sP16 645.613
RNR2642 DVDD__sP11 DVDD__sP17 681.336
RNR2643 DVDD__sP11 DVDD__sP18 934.286
RNR2644 DVDD__sP11 DVDD__sP19 739.254
RNR2645 DVDD__sP11 DVDD__sP20 769.191
RNR2646 DVDD__sP11 DVDD__sP21 791.086
RNR2647 DVDD__sP11 DVDD__sP22 806.459
RNR2648 DVDD__sP11 DVDD__sP23 820.513
RNR2649 DVDD__sP11 DVDD__sP24 828.078
RNR2650 DVDD__sP11 DVDD__sN0 6075.57
RNR2651 DVDD__sP11 DVDD__sN1 8621.57
RNR2652 DVDD__sP11 DVDD__sN2 7077.04
RNR2653 DVDD__sP11 DVDD__sN3 7662.73
RNR2654 DVDD__sP11 DVDD__sN4 8425.33
RNR2655 DVDD__sP11 DVDD__sN5 9115.1
RNR2656 DVDD__sP11 DVDD__sN6 9849.59
RNR2657 DVDD__sP11 DVDD__sN7 10713.2
RNR2658 DVDD__sP11 DVDD__sN8 11549.5
RNR2659 DVDD__sP11 DVDD__sN9 12429
RNR2660 DVDD__sP11 DVDD__sN10 13348
RNR2661 DVDD__sP11 DVDD__sN11 14246.9
RNR2662 DVDD__sP11 DVDD__sN12 15274.8
RNR2663 DVDD__sP11 DVDD__sN13 16269.7
RNR2664 DVDD__sP11 DVDD__sN14 17422.6
RNR2665 DVDD__sP11 DVDD__sN15 24246.3
RNR2666 DVDD__sP11 DVDD__sN16 19399
RNR2667 DVDD__sP11 DVDD__sN17 20472.4
RNR2668 DVDD__sP11 DVDD__sN18 28072.9
RNR2669 DVDD__sP11 DVDD__sN19 22212.7
RNR2670 DVDD__sP11 DVDD__sN20 23112.2
RNR2671 DVDD__sP11 DVDD__sN21 23770.1
RNR2672 DVDD__sP11 DVDD__sN22 24232
RNR2673 DVDD__sP11 DVDD__sN23 24654.3
RNR2674 DVDD__sP11 DVDD__sN24 24881.6
RNR2675 DVDD__sP12 DVDD__sP13 498.611
RNR2676 DVDD__sP12 DVDD__sP14 533.946
RNR2677 DVDD__sP12 DVDD__sP15 743.068
RNR2678 DVDD__sP12 DVDD__sP16 594.515
RNR2679 DVDD__sP12 DVDD__sP17 627.411
RNR2680 DVDD__sP12 DVDD__sP18 860.341
RNR2681 DVDD__sP12 DVDD__sP19 680.745
RNR2682 DVDD__sP12 DVDD__sP20 708.312
RNR2683 DVDD__sP12 DVDD__sP21 728.475
RNR2684 DVDD__sP12 DVDD__sP22 742.631
RNR2685 DVDD__sP12 DVDD__sP23 755.573
RNR2686 DVDD__sP12 DVDD__sP24 762.539
RNR2687 DVDD__sP12 DVDD__sN0 6513.95
RNR2688 DVDD__sP12 DVDD__sN1 9243.66
RNR2689 DVDD__sP12 DVDD__sN2 7587.68
RNR2690 DVDD__sP12 DVDD__sN3 8215.64
RNR2691 DVDD__sP12 DVDD__sN4 9033.26
RNR2692 DVDD__sP12 DVDD__sN5 9772.8
RNR2693 DVDD__sP12 DVDD__sN6 10560.3
RNR2694 DVDD__sP12 DVDD__sN7 11486.2
RNR2695 DVDD__sP12 DVDD__sN8 12382.8
RNR2696 DVDD__sP12 DVDD__sN9 13325.8
RNR2697 DVDD__sP12 DVDD__sN10 14311.2
RNR2698 DVDD__sP12 DVDD__sN11 15274.8
RNR2699 DVDD__sP12 DVDD__sN12 16377
RNR2700 DVDD__sP12 DVDD__sN13 17443.6
RNR2701 DVDD__sP12 DVDD__sN14 18679.7
RNR2702 DVDD__sP12 DVDD__sN15 25995.7
RNR2703 DVDD__sP12 DVDD__sN16 20798.7
RNR2704 DVDD__sP12 DVDD__sN17 21949.6
RNR2705 DVDD__sP12 DVDD__sN18 30098.5
RNR2706 DVDD__sP12 DVDD__sN19 23815.4
RNR2707 DVDD__sP12 DVDD__sN20 24779.8
RNR2708 DVDD__sP12 DVDD__sN21 25485.2
RNR2709 DVDD__sP12 DVDD__sN22 25980.5
RNR2710 DVDD__sP12 DVDD__sN23 26433.2
RNR2711 DVDD__sP12 DVDD__sN24 26676.9
RNR2712 DVDD__sP13 DVDD__sP14 493.043
RNR2713 DVDD__sP13 DVDD__sP15 686.146
RNR2714 DVDD__sP13 DVDD__sP16 548.973
RNR2715 DVDD__sP13 DVDD__sP17 579.349
RNR2716 DVDD__sP13 DVDD__sP18 794.435
RNR2717 DVDD__sP13 DVDD__sP19 628.597
RNR2718 DVDD__sP13 DVDD__sP20 654.052
RNR2719 DVDD__sP13 DVDD__sP21 672.67
RNR2720 DVDD__sP13 DVDD__sP22 685.742
RNR2721 DVDD__sP13 DVDD__sP23 697.693
RNR2722 DVDD__sP13 DVDD__sP24 704.125
RNR2723 DVDD__sP13 DVDD__sN0 6938.19
RNR2724 DVDD__sP13 DVDD__sN1 9845.67
RNR2725 DVDD__sP13 DVDD__sN2 8081.84
RNR2726 DVDD__sP13 DVDD__sN3 8750.7
RNR2727 DVDD__sP13 DVDD__sN4 9621.57
RNR2728 DVDD__sP13 DVDD__sN5 10409.3
RNR2729 DVDD__sP13 DVDD__sN6 11248.1
RNR2730 DVDD__sP13 DVDD__sN7 12234.3
RNR2731 DVDD__sP13 DVDD__sN8 13189.3
RNR2732 DVDD__sP13 DVDD__sN9 14193.7
RNR2733 DVDD__sP13 DVDD__sN10 15243.2
RNR2734 DVDD__sP13 DVDD__sN11 16269.7
RNR2735 DVDD__sP13 DVDD__sN12 17443.6
RNR2736 DVDD__sP13 DVDD__sN13 18579.6
RNR2737 DVDD__sP13 DVDD__sN14 19896.3
RNR2738 DVDD__sP13 DVDD__sN15 27688.8
RNR2739 DVDD__sP13 DVDD__sN16 22153.3
RNR2740 DVDD__sP13 DVDD__sN17 23379.1
RNR2741 DVDD__sP13 DVDD__sN18 32058.7
RNR2742 DVDD__sP13 DVDD__sN19 25366.4
RNR2743 DVDD__sP13 DVDD__sN20 26393.7
RNR2744 DVDD__sP13 DVDD__sN21 27145
RNR2745 DVDD__sP13 DVDD__sN22 27672.5
RNR2746 DVDD__sP13 DVDD__sN23 28154.7
RNR2747 DVDD__sP13 DVDD__sN24 28414.3
RNR2748 DVDD__sP14 DVDD__sP15 625.626
RNR2749 DVDD__sP14 DVDD__sP16 500.553
RNR2750 DVDD__sP14 DVDD__sP17 528.249
RNR2751 DVDD__sP14 DVDD__sP18 724.365
RNR2752 DVDD__sP14 DVDD__sP19 573.154
RNR2753 DVDD__sP14 DVDD__sP20 596.364
RNR2754 DVDD__sP14 DVDD__sP21 613.34
RNR2755 DVDD__sP14 DVDD__sP22 625.259
RNR2756 DVDD__sP14 DVDD__sP23 636.155
RNR2757 DVDD__sP14 DVDD__sP24 642.021
RNR2758 DVDD__sP14 DVDD__sN0 7429.86
RNR2759 DVDD__sP14 DVDD__sN1 10543.4
RNR2760 DVDD__sP14 DVDD__sN2 8654.57
RNR2761 DVDD__sP14 DVDD__sN3 9370.82
RNR2762 DVDD__sP14 DVDD__sN4 10303.4
RNR2763 DVDD__sP14 DVDD__sN5 11146.9
RNR2764 DVDD__sP14 DVDD__sN6 12045.1
RNR2765 DVDD__sP14 DVDD__sN7 13101.2
RNR2766 DVDD__sP14 DVDD__sN8 14123.9
RNR2767 DVDD__sP14 DVDD__sN9 15199.5
RNR2768 DVDD__sP14 DVDD__sN10 16323.4
RNR2769 DVDD__sP14 DVDD__sN11 17422.6
RNR2770 DVDD__sP14 DVDD__sN12 18679.7
RNR2771 DVDD__sP14 DVDD__sN13 19896.3
RNR2772 DVDD__sP14 DVDD__sN14 21306.2
RNR2773 DVDD__sP14 DVDD__sN15 29650.9
RNR2774 DVDD__sP14 DVDD__sN16 23723.2
RNR2775 DVDD__sP14 DVDD__sN17 25035.8
RNR2776 DVDD__sP14 DVDD__sN18 34330.5
RNR2777 DVDD__sP14 DVDD__sN19 27164
RNR2778 DVDD__sP14 DVDD__sN20 28264.1
RNR2779 DVDD__sP14 DVDD__sN21 29068.6
RNR2780 DVDD__sP14 DVDD__sN22 29633.5
RNR2781 DVDD__sP14 DVDD__sN23 30149.9
RNR2782 DVDD__sP14 DVDD__sN24 30427.9
RNR2783 DVDD__sP15 DVDD__sP16 607.557
RNR2784 DVDD__sP15 DVDD__sP17 641.176
RNR2785 DVDD__sP15 DVDD__sP18 879.216
RNR2786 DVDD__sP15 DVDD__sP19 695.68
RNR2787 DVDD__sP15 DVDD__sP20 723.852
RNR2788 DVDD__sP15 DVDD__sP21 744.456
RNR2789 DVDD__sP15 DVDD__sP22 758.923
RNR2790 DVDD__sP15 DVDD__sP23 772.149
RNR2791 DVDD__sP15 DVDD__sP24 779.268
RNR2792 DVDD__sP15 DVDD__sN0 10339.8
RNR2793 DVDD__sP15 DVDD__sN1 14672.8
RNR2794 DVDD__sP15 DVDD__sN2 12044.2
RNR2795 DVDD__sP15 DVDD__sN3 13040.9
RNR2796 DVDD__sP15 DVDD__sN4 14338.8
RNR2797 DVDD__sP15 DVDD__sN5 15512.7
RNR2798 DVDD__sP15 DVDD__sN6 16762.7
RNR2799 DVDD__sP15 DVDD__sN7 18232.4
RNR2800 DVDD__sP15 DVDD__sN8 19655.6
RNR2801 DVDD__sP15 DVDD__sN9 21152.5
RNR2802 DVDD__sP15 DVDD__sN10 22716.6
RNR2803 DVDD__sP15 DVDD__sN11 24246.3
RNR2804 DVDD__sP15 DVDD__sN12 25995.7
RNR2805 DVDD__sP15 DVDD__sN13 27688.8
RNR2806 DVDD__sP15 DVDD__sN14 29650.9
RNR2807 DVDD__sP15 DVDD__sN15 41263.9
RNR2808 DVDD__sP15 DVDD__sN16 33014.5
RNR2809 DVDD__sP15 DVDD__sN17 34841.2
RNR2810 DVDD__sP15 DVDD__sN18 47776.2
RNR2811 DVDD__sP15 DVDD__sN19 37803
RNR2812 DVDD__sP15 DVDD__sN20 39333.8
RNR2813 DVDD__sP15 DVDD__sN21 40453.5
RNR2814 DVDD__sP15 DVDD__sN22 41239.6
RNR2815 DVDD__sP15 DVDD__sN23 41958.3
RNR2816 DVDD__sP15 DVDD__sN24 42345.1
RNR2817 DVDD__sP16 DVDD__sP17 451.921
RNR2818 DVDD__sP16 DVDD__sP18 619.699
RNR2819 DVDD__sP16 DVDD__sP19 490.337
RNR2820 DVDD__sP16 DVDD__sP20 510.194
RNR2821 DVDD__sP16 DVDD__sP21 524.717
RNR2822 DVDD__sP16 DVDD__sP22 534.913
RNR2823 DVDD__sP16 DVDD__sP23 544.235
RNR2824 DVDD__sP16 DVDD__sP24 549.253
RNR2825 DVDD__sP16 DVDD__sN0 8272.69
RNR2826 DVDD__sP16 DVDD__sN1 11739.4
RNR2827 DVDD__sP16 DVDD__sN2 9636.32
RNR2828 DVDD__sP16 DVDD__sN3 10433.8
RNR2829 DVDD__sP16 DVDD__sN4 11472.2
RNR2830 DVDD__sP16 DVDD__sN5 12411.4
RNR2831 DVDD__sP16 DVDD__sN6 13411.5
RNR2832 DVDD__sP16 DVDD__sN7 14587.4
RNR2833 DVDD__sP16 DVDD__sN8 15726.1
RNR2834 DVDD__sP16 DVDD__sN9 16923.7
RNR2835 DVDD__sP16 DVDD__sN10 18175.1
RNR2836 DVDD__sP16 DVDD__sN11 19399
RNR2837 DVDD__sP16 DVDD__sN12 20798.7
RNR2838 DVDD__sP16 DVDD__sN13 22153.3
RNR2839 DVDD__sP16 DVDD__sN14 23723.2
RNR2840 DVDD__sP16 DVDD__sN15 33014.5
RNR2841 DVDD__sP16 DVDD__sN16 26414.3
RNR2842 DVDD__sP16 DVDD__sN17 27875.9
RNR2843 DVDD__sP16 DVDD__sN18 38224.9
RNR2844 DVDD__sP16 DVDD__sN19 30245.5
RNR2845 DVDD__sP16 DVDD__sN20 31470.3
RNR2846 DVDD__sP16 DVDD__sN21 32366.1
RNR2847 DVDD__sP16 DVDD__sN22 32995.1
RNR2848 DVDD__sP16 DVDD__sN23 33570.1
RNR2849 DVDD__sP16 DVDD__sN24 33879.6
RNR2850 DVDD__sP17 DVDD__sP18 567.229
RNR2851 DVDD__sP17 DVDD__sP19 448.821
RNR2852 DVDD__sP17 DVDD__sP20 466.996
RNR2853 DVDD__sP17 DVDD__sP21 480.29
RNR2854 DVDD__sP17 DVDD__sP22 489.623
RNR2855 DVDD__sP17 DVDD__sP23 498.156
RNR2856 DVDD__sP17 DVDD__sP24 502.749
RNR2857 DVDD__sP17 DVDD__sN0 8730.44
RNR2858 DVDD__sP17 DVDD__sN1 12389
RNR2859 DVDD__sP17 DVDD__sN2 10169.5
RNR2860 DVDD__sP17 DVDD__sN3 11011.1
RNR2861 DVDD__sP17 DVDD__sN4 12107
RNR2862 DVDD__sP17 DVDD__sN5 13098.2
RNR2863 DVDD__sP17 DVDD__sN6 14153.6
RNR2864 DVDD__sP17 DVDD__sN7 15394.6
RNR2865 DVDD__sP17 DVDD__sN8 16596.3
RNR2866 DVDD__sP17 DVDD__sN9 17860.1
RNR2867 DVDD__sP17 DVDD__sN10 19180.8
RNR2868 DVDD__sP17 DVDD__sN11 20472.4
RNR2869 DVDD__sP17 DVDD__sN12 21949.6
RNR2870 DVDD__sP17 DVDD__sN13 23379.1
RNR2871 DVDD__sP17 DVDD__sN14 25035.8
RNR2872 DVDD__sP17 DVDD__sN15 34841.2
RNR2873 DVDD__sP17 DVDD__sN16 27875.9
RNR2874 DVDD__sP17 DVDD__sN17 29418.3
RNR2875 DVDD__sP17 DVDD__sN18 40340
RNR2876 DVDD__sP17 DVDD__sN19 31919
RNR2877 DVDD__sP17 DVDD__sN20 33211.6
RNR2878 DVDD__sP17 DVDD__sN21 34157
RNR2879 DVDD__sP17 DVDD__sN22 34820.8
RNR2880 DVDD__sP17 DVDD__sN23 35427.6
RNR2881 DVDD__sP17 DVDD__sN24 35754.2
RNR2882 DVDD__sP18 DVDD__sP19 546.497
RNR2883 DVDD__sP18 DVDD__sP20 568.628
RNR2884 DVDD__sP18 DVDD__sP21 584.814
RNR2885 DVDD__sP18 DVDD__sP22 596.179
RNR2886 DVDD__sP18 DVDD__sP23 606.569
RNR2887 DVDD__sP18 DVDD__sP24 612.161
RNR2888 DVDD__sP18 DVDD__sN0 11971.7
RNR2889 DVDD__sP18 DVDD__sN1 16988.5
RNR2890 DVDD__sP18 DVDD__sN2 13945
RNR2891 DVDD__sP18 DVDD__sN3 15099.1
RNR2892 DVDD__sP18 DVDD__sN4 16601.8
RNR2893 DVDD__sP18 DVDD__sN5 17960.9
RNR2894 DVDD__sP18 DVDD__sN6 19408.2
RNR2895 DVDD__sP18 DVDD__sN7 21109.9
RNR2896 DVDD__sP18 DVDD__sN8 22757.7
RNR2897 DVDD__sP18 DVDD__sN9 24490.8
RNR2898 DVDD__sP18 DVDD__sN10 26301.8
RNR2899 DVDD__sP18 DVDD__sN11 28072.9
RNR2900 DVDD__sP18 DVDD__sN12 30098.5
RNR2901 DVDD__sP18 DVDD__sN13 32058.7
RNR2902 DVDD__sP18 DVDD__sN14 34330.5
RNR2903 DVDD__sP18 DVDD__sN15 47776.2
RNR2904 DVDD__sP18 DVDD__sN16 38224.9
RNR2905 DVDD__sP18 DVDD__sN17 40340
RNR2906 DVDD__sP18 DVDD__sN18 55316.4
RNR2907 DVDD__sP18 DVDD__sN19 43769.1
RNR2908 DVDD__sP18 DVDD__sN20 45541.6
RNR2909 DVDD__sP18 DVDD__sN21 46837.9
RNR2910 DVDD__sP18 DVDD__sN22 47748.1
RNR2911 DVDD__sP18 DVDD__sN23 48580.3
RNR2912 DVDD__sP18 DVDD__sN24 49028.2
RNR2913 DVDD__sP19 DVDD__sP20 398.866
RNR2914 DVDD__sP19 DVDD__sP21 410.22
RNR2915 DVDD__sP19 DVDD__sP22 418.192
RNR2916 DVDD__sP19 DVDD__sP23 425.48
RNR2917 DVDD__sP19 DVDD__sP24 429.403
RNR2918 DVDD__sP19 DVDD__sN0 9472.58
RNR2919 DVDD__sP19 DVDD__sN1 13442.1
RNR2920 DVDD__sP19 DVDD__sN2 11034
RNR2921 DVDD__sP19 DVDD__sN3 11947.2
RNR2922 DVDD__sP19 DVDD__sN4 13136.1
RNR2923 DVDD__sP19 DVDD__sN5 14211.6
RNR2924 DVDD__sP19 DVDD__sN6 15356.8
RNR2925 DVDD__sP19 DVDD__sN7 16703.2
RNR2926 DVDD__sP19 DVDD__sN8 18007.1
RNR2927 DVDD__sP19 DVDD__sN9 19378.3
RNR2928 DVDD__sP19 DVDD__sN10 20811.3
RNR2929 DVDD__sP19 DVDD__sN11 22212.7
RNR2930 DVDD__sP19 DVDD__sN12 23815.4
RNR2931 DVDD__sP19 DVDD__sN13 25366.4
RNR2932 DVDD__sP19 DVDD__sN14 27164
RNR2933 DVDD__sP19 DVDD__sN15 37803
RNR2934 DVDD__sP19 DVDD__sN16 30245.5
RNR2935 DVDD__sP19 DVDD__sN17 31919
RNR2936 DVDD__sP19 DVDD__sN18 43769.1
RNR2937 DVDD__sP19 DVDD__sN19 34632.3
RNR2938 DVDD__sP19 DVDD__sN20 36034.8
RNR2939 DVDD__sP19 DVDD__sN21 37060.5
RNR2940 DVDD__sP19 DVDD__sN22 37780.7
RNR2941 DVDD__sP19 DVDD__sN23 38439.1
RNR2942 DVDD__sP19 DVDD__sN24 38793.5
RNR2943 DVDD__sP20 DVDD__sP21 374.043
RNR2944 DVDD__sP20 DVDD__sP22 381.312
RNR2945 DVDD__sP20 DVDD__sP23 387.957
RNR2946 DVDD__sP20 DVDD__sP24 391.534
RNR2947 DVDD__sP20 DVDD__sN0 9856.18
RNR2948 DVDD__sP20 DVDD__sN1 13986.5
RNR2949 DVDD__sP20 DVDD__sN2 11480.8
RNR2950 DVDD__sP20 DVDD__sN3 12431
RNR2951 DVDD__sP20 DVDD__sN4 13668.1
RNR2952 DVDD__sP20 DVDD__sN5 14787.1
RNR2953 DVDD__sP20 DVDD__sN6 15978.6
RNR2954 DVDD__sP20 DVDD__sN7 17379.6
RNR2955 DVDD__sP20 DVDD__sN8 18736.3
RNR2956 DVDD__sP20 DVDD__sN9 20163.1
RNR2957 DVDD__sP20 DVDD__sN10 21654
RNR2958 DVDD__sP20 DVDD__sN11 23112.2
RNR2959 DVDD__sP20 DVDD__sN12 24779.8
RNR2960 DVDD__sP20 DVDD__sN13 26393.7
RNR2961 DVDD__sP20 DVDD__sN14 28264.1
RNR2962 DVDD__sP20 DVDD__sN15 39333.8
RNR2963 DVDD__sP20 DVDD__sN16 31470.3
RNR2964 DVDD__sP20 DVDD__sN17 33211.6
RNR2965 DVDD__sP20 DVDD__sN18 45541.6
RNR2966 DVDD__sP20 DVDD__sN19 36034.8
RNR2967 DVDD__sP20 DVDD__sN20 37494
RNR2968 DVDD__sP20 DVDD__sN21 38561.3
RNR2969 DVDD__sP20 DVDD__sN22 39310.7
RNR2970 DVDD__sP20 DVDD__sN23 39995.8
RNR2971 DVDD__sP20 DVDD__sN24 40364.5
RNR2972 DVDD__sP21 DVDD__sP22 351.673
RNR2973 DVDD__sP21 DVDD__sP23 357.802
RNR2974 DVDD__sP21 DVDD__sP24 361.101
RNR2975 DVDD__sP21 DVDD__sN0 10136.7
RNR2976 DVDD__sP21 DVDD__sN1 14384.6
RNR2977 DVDD__sP21 DVDD__sN2 11807.6
RNR2978 DVDD__sP21 DVDD__sN3 12784.8
RNR2979 DVDD__sP21 DVDD__sN4 14057.2
RNR2980 DVDD__sP21 DVDD__sN5 15208
RNR2981 DVDD__sP21 DVDD__sN6 16433.5
RNR2982 DVDD__sP21 DVDD__sN7 17874.3
RNR2983 DVDD__sP21 DVDD__sN8 19269.6
RNR2984 DVDD__sP21 DVDD__sN9 20737
RNR2985 DVDD__sP21 DVDD__sN10 22270.4
RNR2986 DVDD__sP21 DVDD__sN11 23770.1
RNR2987 DVDD__sP21 DVDD__sN12 25485.2
RNR2988 DVDD__sP21 DVDD__sN13 27145
RNR2989 DVDD__sP21 DVDD__sN14 29068.6
RNR2990 DVDD__sP21 DVDD__sN15 40453.5
RNR2991 DVDD__sP21 DVDD__sN16 32366.1
RNR2992 DVDD__sP21 DVDD__sN17 34157
RNR2993 DVDD__sP21 DVDD__sN18 46837.9
RNR2994 DVDD__sP21 DVDD__sN19 37060.5
RNR2995 DVDD__sP21 DVDD__sN20 38561.3
RNR2996 DVDD__sP21 DVDD__sN21 39659
RNR2997 DVDD__sP21 DVDD__sN22 40429.7
RNR2998 DVDD__sP21 DVDD__sN23 41134.3
RNR2999 DVDD__sP21 DVDD__sN24 41513.5
RNR3000 DVDD__sP22 DVDD__sP23 332.354
RNR3001 DVDD__sP22 DVDD__sP24 335.418
RNR3002 DVDD__sP22 DVDD__sN0 10333.7
RNR3003 DVDD__sP22 DVDD__sN1 14664.1
RNR3004 DVDD__sP22 DVDD__sN2 12037.1
RNR3005 DVDD__sP22 DVDD__sN3 13033.3
RNR3006 DVDD__sP22 DVDD__sN4 14330.3
RNR3007 DVDD__sP22 DVDD__sN5 15503.6
RNR3008 DVDD__sP22 DVDD__sN6 16752.8
RNR3009 DVDD__sP22 DVDD__sN7 18221.7
RNR3010 DVDD__sP22 DVDD__sN8 19644.1
RNR3011 DVDD__sP22 DVDD__sN9 21140
RNR3012 DVDD__sP22 DVDD__sN10 22703.2
RNR3013 DVDD__sP22 DVDD__sN11 24232
RNR3014 DVDD__sP22 DVDD__sN12 25980.5
RNR3015 DVDD__sP22 DVDD__sN13 27672.5
RNR3016 DVDD__sP22 DVDD__sN14 29633.5
RNR3017 DVDD__sP22 DVDD__sN15 41239.6
RNR3018 DVDD__sP22 DVDD__sN16 32995.1
RNR3019 DVDD__sP22 DVDD__sN17 34820.8
RNR3020 DVDD__sP22 DVDD__sN18 47748.1
RNR3021 DVDD__sP22 DVDD__sN19 37780.7
RNR3022 DVDD__sP22 DVDD__sN20 39310.7
RNR3023 DVDD__sP22 DVDD__sN21 40429.7
RNR3024 DVDD__sP22 DVDD__sN22 41215.3
RNR3025 DVDD__sP22 DVDD__sN23 41933.6
RNR3026 DVDD__sP22 DVDD__sN24 42320.2
RNR3027 DVDD__sP23 DVDD__sP24 303.962
RNR3028 DVDD__sP23 DVDD__sN0 10513.8
RNR3029 DVDD__sP23 DVDD__sN1 14919.7
RNR3030 DVDD__sP23 DVDD__sN2 12246.9
RNR3031 DVDD__sP23 DVDD__sN3 13260.4
RNR3032 DVDD__sP23 DVDD__sN4 14580.1
RNR3033 DVDD__sP23 DVDD__sN5 15773.7
RNR3034 DVDD__sP23 DVDD__sN6 17044.8
RNR3035 DVDD__sP23 DVDD__sN7 18539.2
RNR3036 DVDD__sP23 DVDD__sN8 19986.4
RNR3037 DVDD__sP23 DVDD__sN9 21508.4
RNR3038 DVDD__sP23 DVDD__sN10 23098.9
RNR3039 DVDD__sP23 DVDD__sN11 24654.3
RNR3040 DVDD__sP23 DVDD__sN12 26433.2
RNR3041 DVDD__sP23 DVDD__sN13 28154.7
RNR3042 DVDD__sP23 DVDD__sN14 30149.9
RNR3043 DVDD__sP23 DVDD__sN15 41958.3
RNR3044 DVDD__sP23 DVDD__sN16 33570.1
RNR3045 DVDD__sP23 DVDD__sN17 35427.6
RNR3046 DVDD__sP23 DVDD__sN18 48580.3
RNR3047 DVDD__sP23 DVDD__sN19 38439.1
RNR3048 DVDD__sP23 DVDD__sN20 39995.8
RNR3049 DVDD__sP23 DVDD__sN21 41134.3
RNR3050 DVDD__sP23 DVDD__sN22 41933.6
RNR3051 DVDD__sP23 DVDD__sN23 42664.4
RNR3052 DVDD__sP23 DVDD__sN24 43057.8
RNR3053 DVDD__sP24 DVDD__sN0 10610.7
RNR3054 DVDD__sP24 DVDD__sN1 15057.2
RNR3055 DVDD__sP24 DVDD__sN2 12359.8
RNR3056 DVDD__sP24 DVDD__sN3 13382.7
RNR3057 DVDD__sP24 DVDD__sN4 14714.5
RNR3058 DVDD__sP24 DVDD__sN5 15919.2
RNR3059 DVDD__sP24 DVDD__sN6 17201.9
RNR3060 DVDD__sP24 DVDD__sN7 18710.2
RNR3061 DVDD__sP24 DVDD__sN8 20170.7
RNR3062 DVDD__sP24 DVDD__sN9 21706.7
RNR3063 DVDD__sP24 DVDD__sN10 23311.8
RNR3064 DVDD__sP24 DVDD__sN11 24881.6
RNR3065 DVDD__sP24 DVDD__sN12 26676.9
RNR3066 DVDD__sP24 DVDD__sN13 28414.3
RNR3067 DVDD__sP24 DVDD__sN14 30427.9
RNR3068 DVDD__sP24 DVDD__sN15 42345.1
RNR3069 DVDD__sP24 DVDD__sN16 33879.6
RNR3070 DVDD__sP24 DVDD__sN17 35754.2
RNR3071 DVDD__sP24 DVDD__sN18 49028.2
RNR3072 DVDD__sP24 DVDD__sN19 38793.5
RNR3073 DVDD__sP24 DVDD__sN20 40364.5
RNR3074 DVDD__sP24 DVDD__sN21 41513.5
RNR3075 DVDD__sP24 DVDD__sN22 42320.2
RNR3076 DVDD__sP24 DVDD__sN23 43057.8
RNR3077 DVDD__sP24 DVDD__sN24 43454.8
RNR3078 DVDD__sN0 DVDD__sN1 547.704
RNR3079 DVDD__sN0 DVDD__sN2 449.585
RNR3080 DVDD__sN0 DVDD__sN3 486.792
RNR3081 DVDD__sN0 DVDD__sN4 535.238
RNR3082 DVDD__sN0 DVDD__sN5 579.057
RNR3083 DVDD__sN0 DVDD__sN6 625.718
RNR3084 DVDD__sN0 DVDD__sN7 680.579
RNR3085 DVDD__sN0 DVDD__sN8 733.706
RNR3086 DVDD__sN0 DVDD__sN9 789.579
RNR3087 DVDD__sN0 DVDD__sN10 847.965
RNR3088 DVDD__sN0 DVDD__sN11 905.064
RNR3089 DVDD__sN0 DVDD__sN12 970.369
RNR3090 DVDD__sN0 DVDD__sN13 1033.57
RNR3091 DVDD__sN0 DVDD__sN14 1106.81
RNR3092 DVDD__sN0 DVDD__sN15 1540.3
RNR3093 DVDD__sN0 DVDD__sN16 1232.36
RNR3094 DVDD__sN0 DVDD__sN17 1300.55
RNR3095 DVDD__sN0 DVDD__sN18 1783.39
RNR3096 DVDD__sN0 DVDD__sN19 1411.11
RNR3097 DVDD__sN0 DVDD__sN20 1468.25
RNR3098 DVDD__sN0 DVDD__sN21 1510.05
RNR3099 DVDD__sN0 DVDD__sN22 1539.39
RNR3100 DVDD__sN0 DVDD__sN23 1566.22
RNR3101 DVDD__sN0 DVDD__sN24 1580.66
RNR3102 DVDD__sN1 DVDD__sN2 568.702
RNR3103 DVDD__sN1 DVDD__sN3 615.769
RNR3104 DVDD__sN1 DVDD__sN4 677.051
RNR3105 DVDD__sN1 DVDD__sN5 732.48
RNR3106 DVDD__sN1 DVDD__sN6 791.503
RNR3107 DVDD__sN1 DVDD__sN7 860.9
RNR3108 DVDD__sN1 DVDD__sN8 928.103
RNR3109 DVDD__sN1 DVDD__sN9 998.78
RNR3110 DVDD__sN1 DVDD__sN10 1072.63
RNR3111 DVDD__sN1 DVDD__sN11 1144.86
RNR3112 DVDD__sN1 DVDD__sN12 1227.47
RNR3113 DVDD__sN1 DVDD__sN13 1307.41
RNR3114 DVDD__sN1 DVDD__sN14 1400.06
RNR3115 DVDD__sN1 DVDD__sN15 1948.4
RNR3116 DVDD__sN1 DVDD__sN16 1558.88
RNR3117 DVDD__sN1 DVDD__sN17 1645.14
RNR3118 DVDD__sN1 DVDD__sN18 2255.9
RNR3119 DVDD__sN1 DVDD__sN19 1784.99
RNR3120 DVDD__sN1 DVDD__sN20 1857.27
RNR3121 DVDD__sN1 DVDD__sN21 1910.14
RNR3122 DVDD__sN1 DVDD__sN22 1947.26
RNR3123 DVDD__sN1 DVDD__sN23 1981.19
RNR3124 DVDD__sN1 DVDD__sN24 1999.46
RNR3125 DVDD__sN2 DVDD__sN3 448.696
RNR3126 DVDD__sN2 DVDD__sN4 493.351
RNR3127 DVDD__sN2 DVDD__sN5 533.742
RNR3128 DVDD__sN2 DVDD__sN6 576.75
RNR3129 DVDD__sN2 DVDD__sN7 627.319
RNR3130 DVDD__sN2 DVDD__sN8 676.288
RNR3131 DVDD__sN2 DVDD__sN9 727.788
RNR3132 DVDD__sN2 DVDD__sN10 781.604
RNR3133 DVDD__sN2 DVDD__sN11 834.236
RNR3134 DVDD__sN2 DVDD__sN12 894.43
RNR3135 DVDD__sN2 DVDD__sN13 952.682
RNR3136 DVDD__sN2 DVDD__sN14 1020.19
RNR3137 DVDD__sN2 DVDD__sN15 1419.76
RNR3138 DVDD__sN2 DVDD__sN16 1135.92
RNR3139 DVDD__sN2 DVDD__sN17 1198.78
RNR3140 DVDD__sN2 DVDD__sN18 1643.83
RNR3141 DVDD__sN2 DVDD__sN19 1300.68
RNR3142 DVDD__sN2 DVDD__sN20 1353.35
RNR3143 DVDD__sN2 DVDD__sN21 1391.87
RNR3144 DVDD__sN2 DVDD__sN22 1418.92
RNR3145 DVDD__sN2 DVDD__sN23 1443.65
RNR3146 DVDD__sN2 DVDD__sN24 1456.96
RNR3147 DVDD__sN3 DVDD__sN4 469.352
RNR3148 DVDD__sN3 DVDD__sN5 507.778
RNR3149 DVDD__sN3 DVDD__sN6 548.694
RNR3150 DVDD__sN3 DVDD__sN7 596.803
RNR3151 DVDD__sN3 DVDD__sN8 643.39
RNR3152 DVDD__sN3 DVDD__sN9 692.385
RNR3153 DVDD__sN3 DVDD__sN10 743.583
RNR3154 DVDD__sN3 DVDD__sN11 793.654
RNR3155 DVDD__sN3 DVDD__sN12 850.921
RNR3156 DVDD__sN3 DVDD__sN13 906.338
RNR3157 DVDD__sN3 DVDD__sN14 970.566
RNR3158 DVDD__sN3 DVDD__sN15 1350.69
RNR3159 DVDD__sN3 DVDD__sN16 1080.67
RNR3160 DVDD__sN3 DVDD__sN17 1140.46
RNR3161 DVDD__sN3 DVDD__sN18 1563.86
RNR3162 DVDD__sN3 DVDD__sN19 1237.41
RNR3163 DVDD__sN3 DVDD__sN20 1287.52
RNR3164 DVDD__sN3 DVDD__sN21 1324.17
RNR3165 DVDD__sN3 DVDD__sN22 1349.9
RNR3166 DVDD__sN3 DVDD__sN23 1373.42
RNR3167 DVDD__sN3 DVDD__sN24 1386.09
RNR3168 DVDD__sN4 DVDD__sN5 475.847
RNR3169 DVDD__sN4 DVDD__sN6 514.191
RNR3170 DVDD__sN4 DVDD__sN7 559.275
RNR3171 DVDD__sN4 DVDD__sN8 602.932
RNR3172 DVDD__sN4 DVDD__sN9 648.847
RNR3173 DVDD__sN4 DVDD__sN10 696.826
RNR3174 DVDD__sN4 DVDD__sN11 743.748
RNR3175 DVDD__sN4 DVDD__sN12 797.413
RNR3176 DVDD__sN4 DVDD__sN13 849.346
RNR3177 DVDD__sN4 DVDD__sN14 909.536
RNR3178 DVDD__sN4 DVDD__sN15 1265.76
RNR3179 DVDD__sN4 DVDD__sN16 1012.71
RNR3180 DVDD__sN4 DVDD__sN17 1068.75
RNR3181 DVDD__sN4 DVDD__sN18 1465.52
RNR3182 DVDD__sN4 DVDD__sN19 1159.6
RNR3183 DVDD__sN4 DVDD__sN20 1206.56
RNR3184 DVDD__sN4 DVDD__sN21 1240.9
RNR3185 DVDD__sN4 DVDD__sN22 1265.01
RNR3186 DVDD__sN4 DVDD__sN23 1287.06
RNR3187 DVDD__sN4 DVDD__sN24 1298.93
RNR3188 DVDD__sN5 DVDD__sN6 485.212
RNR3189 DVDD__sN5 DVDD__sN7 527.755
RNR3190 DVDD__sN5 DVDD__sN8 568.953
RNR3191 DVDD__sN5 DVDD__sN9 612.279
RNR3192 DVDD__sN5 DVDD__sN10 657.554
RNR3193 DVDD__sN5 DVDD__sN11 701.832
RNR3194 DVDD__sN5 DVDD__sN12 752.473
RNR3195 DVDD__sN5 DVDD__sN13 801.479
RNR3196 DVDD__sN5 DVDD__sN14 858.277
RNR3197 DVDD__sN5 DVDD__sN15 1194.42
RNR3198 DVDD__sN5 DVDD__sN16 955.638
RNR3199 DVDD__sN5 DVDD__sN17 1008.52
RNR3200 DVDD__sN5 DVDD__sN18 1382.93
RNR3201 DVDD__sN5 DVDD__sN19 1094.24
RNR3202 DVDD__sN5 DVDD__sN20 1138.56
RNR3203 DVDD__sN5 DVDD__sN21 1170.97
RNR3204 DVDD__sN5 DVDD__sN22 1193.72
RNR3205 DVDD__sN5 DVDD__sN23 1214.53
RNR3206 DVDD__sN5 DVDD__sN24 1225.72
RNR3207 DVDD__sN6 DVDD__sN7 496.171
RNR3208 DVDD__sN6 DVDD__sN8 534.903
RNR3209 DVDD__sN6 DVDD__sN9 575.637
RNR3210 DVDD__sN6 DVDD__sN10 618.202
RNR3211 DVDD__sN6 DVDD__sN11 659.83
RNR3212 DVDD__sN6 DVDD__sN12 707.441
RNR3213 DVDD__sN6 DVDD__sN13 753.514
RNR3214 DVDD__sN6 DVDD__sN14 806.912
RNR3215 DVDD__sN6 DVDD__sN15 1122.94
RNR3216 DVDD__sN6 DVDD__sN16 898.446
RNR3217 DVDD__sN6 DVDD__sN17 948.159
RNR3218 DVDD__sN6 DVDD__sN18 1300.17
RNR3219 DVDD__sN6 DVDD__sN19 1028.76
RNR3220 DVDD__sN6 DVDD__sN20 1070.42
RNR3221 DVDD__sN6 DVDD__sN21 1100.89
RNR3222 DVDD__sN6 DVDD__sN22 1122.28
RNR3223 DVDD__sN6 DVDD__sN23 1141.84
RNR3224 DVDD__sN6 DVDD__sN24 1152.37
RNR3225 DVDD__sN7 DVDD__sN8 498.112
RNR3226 DVDD__sN7 DVDD__sN9 536.045
RNR3227 DVDD__sN7 DVDD__sN10 575.683
RNR3228 DVDD__sN7 DVDD__sN11 614.448
RNR3229 DVDD__sN7 DVDD__sN12 658.784
RNR3230 DVDD__sN7 DVDD__sN13 701.688
RNR3231 DVDD__sN7 DVDD__sN14 751.414
RNR3232 DVDD__sN7 DVDD__sN15 1045.71
RNR3233 DVDD__sN7 DVDD__sN16 836.652
RNR3234 DVDD__sN7 DVDD__sN17 882.946
RNR3235 DVDD__sN7 DVDD__sN18 1210.74
RNR3236 DVDD__sN7 DVDD__sN19 958.002
RNR3237 DVDD__sN7 DVDD__sN20 996.797
RNR3238 DVDD__sN7 DVDD__sN21 1025.17
RNR3239 DVDD__sN7 DVDD__sN22 1045.09
RNR3240 DVDD__sN7 DVDD__sN23 1063.31
RNR3241 DVDD__sN7 DVDD__sN24 1073.11
RNR3242 DVDD__sN8 DVDD__sN9 501.059
RNR3243 DVDD__sN8 DVDD__sN10 538.11
RNR3244 DVDD__sN8 DVDD__sN11 574.345
RNR3245 DVDD__sN8 DVDD__sN12 615.787
RNR3246 DVDD__sN8 DVDD__sN13 655.891
RNR3247 DVDD__sN8 DVDD__sN14 702.371
RNR3248 DVDD__sN8 DVDD__sN15 977.458
RNR3249 DVDD__sN8 DVDD__sN16 782.047
RNR3250 DVDD__sN8 DVDD__sN17 825.319
RNR3251 DVDD__sN8 DVDD__sN18 1131.72
RNR3252 DVDD__sN8 DVDD__sN19 895.476
RNR3253 DVDD__sN8 DVDD__sN20 931.739
RNR3254 DVDD__sN8 DVDD__sN21 958.262
RNR3255 DVDD__sN8 DVDD__sN22 976.883
RNR3256 DVDD__sN8 DVDD__sN23 993.908
RNR3257 DVDD__sN8 DVDD__sN24 1003.07
RNR3258 DVDD__sN9 DVDD__sN10 501.703
RNR3259 DVDD__sN9 DVDD__sN11 535.487
RNR3260 DVDD__sN9 DVDD__sN12 574.126
RNR3261 DVDD__sN9 DVDD__sN13 611.517
RNR3262 DVDD__sN9 DVDD__sN14 654.852
RNR3263 DVDD__sN9 DVDD__sN15 911.328
RNR3264 DVDD__sN9 DVDD__sN16 729.137
RNR3265 DVDD__sN9 DVDD__sN17 769.482
RNR3266 DVDD__sN9 DVDD__sN18 1055.16
RNR3267 DVDD__sN9 DVDD__sN19 834.892
RNR3268 DVDD__sN9 DVDD__sN20 868.702
RNR3269 DVDD__sN9 DVDD__sN21 893.43
RNR3270 DVDD__sN9 DVDD__sN22 910.792
RNR3271 DVDD__sN9 DVDD__sN23 926.664
RNR3272 DVDD__sN9 DVDD__sN24 935.208
RNR3273 DVDD__sN10 DVDD__sN11 498.148
RNR3274 DVDD__sN10 DVDD__sN12 534.093
RNR3275 DVDD__sN10 DVDD__sN13 568.877
RNR3276 DVDD__sN10 DVDD__sN14 609.191
RNR3277 DVDD__sN10 DVDD__sN15 847.783
RNR3278 DVDD__sN10 DVDD__sN16 678.296
RNR3279 DVDD__sN10 DVDD__sN17 715.828
RNR3280 DVDD__sN10 DVDD__sN18 981.583
RNR3281 DVDD__sN10 DVDD__sN19 776.677
RNR3282 DVDD__sN10 DVDD__sN20 808.13
RNR3283 DVDD__sN10 DVDD__sN21 831.133
RNR3284 DVDD__sN10 DVDD__sN22 847.285
RNR3285 DVDD__sN10 DVDD__sN23 862.051
RNR3286 DVDD__sN10 DVDD__sN24 869.999
RNR3287 DVDD__sN11 DVDD__sN12 497.503
RNR3288 DVDD__sN11 DVDD__sN13 529.904
RNR3289 DVDD__sN11 DVDD__sN14 567.456
RNR3290 DVDD__sN11 DVDD__sN15 789.703
RNR3291 DVDD__sN11 DVDD__sN16 631.827
RNR3292 DVDD__sN11 DVDD__sN17 666.787
RNR3293 DVDD__sN11 DVDD__sN18 914.336
RNR3294 DVDD__sN11 DVDD__sN19 723.468
RNR3295 DVDD__sN11 DVDD__sN20 752.766
RNR3296 DVDD__sN11 DVDD__sN21 774.194
RNR3297 DVDD__sN11 DVDD__sN22 789.238
RNR3298 DVDD__sN11 DVDD__sN23 802.993
RNR3299 DVDD__sN11 DVDD__sN24 810.396
RNR3300 DVDD__sN12 DVDD__sN13 489.439
RNR3301 DVDD__sN12 DVDD__sN14 524.123
RNR3302 DVDD__sN12 DVDD__sN15 729.399
RNR3303 DVDD__sN12 DVDD__sN16 583.579
RNR3304 DVDD__sN12 DVDD__sN17 615.869
RNR3305 DVDD__sN12 DVDD__sN18 844.514
RNR3306 DVDD__sN12 DVDD__sN19 668.222
RNR3307 DVDD__sN12 DVDD__sN20 695.282
RNR3308 DVDD__sN12 DVDD__sN21 715.074
RNR3309 DVDD__sN12 DVDD__sN22 728.97
RNR3310 DVDD__sN12 DVDD__sN23 741.674
RNR3311 DVDD__sN12 DVDD__sN24 748.512
RNR3312 DVDD__sN13 DVDD__sN14 485.161
RNR3313 DVDD__sN13 DVDD__sN15 675.176
RNR3314 DVDD__sN13 DVDD__sN16 540.196
RNR3315 DVDD__sN13 DVDD__sN17 570.087
RNR3316 DVDD__sN13 DVDD__sN18 781.734
RNR3317 DVDD__sN13 DVDD__sN19 618.548
RNR3318 DVDD__sN13 DVDD__sN20 643.596
RNR3319 DVDD__sN13 DVDD__sN21 661.916
RNR3320 DVDD__sN13 DVDD__sN22 674.779
RNR3321 DVDD__sN13 DVDD__sN23 686.539
RNR3322 DVDD__sN13 DVDD__sN24 692.869
RNR3323 DVDD__sN14 DVDD__sN15 617.09
RNR3324 DVDD__sN14 DVDD__sN16 493.723
RNR3325 DVDD__sN14 DVDD__sN17 521.042
RNR3326 DVDD__sN14 DVDD__sN18 714.481
RNR3327 DVDD__sN14 DVDD__sN19 565.333
RNR3328 DVDD__sN14 DVDD__sN20 588.227
RNR3329 DVDD__sN14 DVDD__sN21 604.971
RNR3330 DVDD__sN14 DVDD__sN22 616.727
RNR3331 DVDD__sN14 DVDD__sN23 627.475
RNR3332 DVDD__sN14 DVDD__sN24 633.261
RNR3333 DVDD__sN15 DVDD__sN16 600.314
RNR3334 DVDD__sN15 DVDD__sN17 633.532
RNR3335 DVDD__sN15 DVDD__sN18 868.734
RNR3336 DVDD__sN15 DVDD__sN19 687.386
RNR3337 DVDD__sN15 DVDD__sN20 715.222
RNR3338 DVDD__sN15 DVDD__sN21 735.582
RNR3339 DVDD__sN15 DVDD__sN22 749.876
RNR3340 DVDD__sN15 DVDD__sN23 762.944
RNR3341 DVDD__sN15 DVDD__sN24 769.978
RNR3342 DVDD__sN16 DVDD__sN17 447.168
RNR3343 DVDD__sN16 DVDD__sN18 613.182
RNR3344 DVDD__sN16 DVDD__sN19 485.18
RNR3345 DVDD__sN16 DVDD__sN20 504.828
RNR3346 DVDD__sN16 DVDD__sN21 519.198
RNR3347 DVDD__sN16 DVDD__sN22 529.288
RNR3348 DVDD__sN16 DVDD__sN23 538.512
RNR3349 DVDD__sN16 DVDD__sN24 543.477
RNR3350 DVDD__sN17 DVDD__sN18 562.048
RNR3351 DVDD__sN17 DVDD__sN19 444.721
RNR3352 DVDD__sN17 DVDD__sN20 462.73
RNR3353 DVDD__sN17 DVDD__sN21 475.902
RNR3354 DVDD__sN17 DVDD__sN22 485.15
RNR3355 DVDD__sN17 DVDD__sN23 493.605
RNR3356 DVDD__sN17 DVDD__sN24 498.156
RNR3357 DVDD__sN18 DVDD__sN19 542.059
RNR3358 DVDD__sN18 DVDD__sN20 564.011
RNR3359 DVDD__sN18 DVDD__sN21 580.066
RNR3360 DVDD__sN18 DVDD__sN22 591.338
RNR3361 DVDD__sN18 DVDD__sN23 601.644
RNR3362 DVDD__sN18 DVDD__sN24 607.191
RNR3363 DVDD__sN19 DVDD__sN20 395.992
RNR3364 DVDD__sN19 DVDD__sN21 407.265
RNR3365 DVDD__sN19 DVDD__sN22 415.179
RNR3366 DVDD__sN19 DVDD__sN23 422.414
RNR3367 DVDD__sN19 DVDD__sN24 426.309
RNR3368 DVDD__sN20 DVDD__sN21 371.679
RNR3369 DVDD__sN20 DVDD__sN22 378.902
RNR3370 DVDD__sN20 DVDD__sN23 385.506
RNR3371 DVDD__sN20 DVDD__sN24 389.06
RNR3372 DVDD__sN21 DVDD__sN22 349.679
RNR3373 DVDD__sN21 DVDD__sN23 355.773
RNR3374 DVDD__sN21 DVDD__sN24 359.053
RNR3375 DVDD__sN22 DVDD__sN23 330.636
RNR3376 DVDD__sN22 DVDD__sN24 333.684
RNR3377 DVDD__sN23 DVDD__sN24 302.562
RTUP10 a_78592_93106_r# a_78592_93106# 50.754
RTUN5 a_73472_152994_r# a_73472_152994# 48.0737
RTUP2 a_70400_93106_r# a_70400_93106# 47.4337
RTUP8 a_76544_93106_r# a_76544_93106# 48.6855
RTUN7 a_75520_152994_r# a_75520_152994# 48.2996
RTUN19 a_87808_152994_r# a_87808_152994# 67.789
RTUN11 a_79616_152994_r# a_79616_152994# 50.8
RTUN12 a_80640_152994_r# a_80640_152994# 58.7278
RTUP16 a_84736_93106_r# a_84736_93106# 74.6671
RTUP18 a_86784_93106_r# a_86784_93106# 75.2218
RTUN9 a_77568_152994_r# a_77568_152994# 48.8398
RTUN1 a_69376_152994_r# a_69376_152994# 62.2645
RTUP4 a_72448_93106_r# a_72448_93106# 45.4582
RTUP17 a_85760_93106_r# a_85760_93106# 67.1126
RTUP24 a_92928_93106_r# a_92928_93106# 73.7281
RTUN21 a_89856_152994_r# a_89856_152994# 53.7744
RTUN23 a_91904_152994_r# a_91904_152994# 54.544
RTUN6 a_74496_152994_r# a_74496_152994# 48.2664
RTUN15 a_83712_152994_r# a_83712_152994# 66.6707
RTUP22 a_90880_93106_r# a_90880_93106# 61.3472
RTUP15 a_83712_93106_r# a_83712_93106# 66.696
RTUP1 a_69376_93106_r# a_69376_93106# 62.2726
RTUP13 a_81664_93106_r# a_81664_93106# 51.2265
RTUP20 a_88832_93106_r# a_88832_93106# 53.3935
RTUN20 a_88832_152994_r# a_88832_152994# 53.3708
RTUP6 a_74496_93106_r# a_74496_93106# 48.2876
RTUP11 a_79616_93106_r# a_79616_93106# 50.8252
RTUN2 a_70400_152994_r# a_70400_152994# 47.4305
RTUN13 a_81664_152994_r# a_81664_152994# 51.2009
RTUN16 a_84736_152994_r# a_84736_152994# 74.6112
RTUN4 a_72448_152994_r# a_72448_152994# 45.4427
RTUP5 a_73472_93106_r# a_73472_93106# 48.0941
RTUN10 a_78592_152994_r# a_78592_152994# 50.7315
RTUP7 a_75520_93106_r# a_75520_93106# 48.3207
RTUN24 a_92928_152994_r# a_92928_152994# 73.6468
RTUN18 a_86784_152994_r# a_86784_152994# 75.1706
RTUN17 a_85760_152994_r# a_85760_152994# 67.0868
RTUN0 a_68216_149604_r# a_68216_149604# 77.2108
RTUP21 a_89856_93106_r# a_89856_93106# 53.803
RTUN3 a_71424_152994_r# a_71424_152994# 45.3115
RTUP23 a_91904_93106_r# a_91904_93106# 54.5668
RTUP3 a_71424_93106_r# a_71424_93106# 45.3123
RTUP9 a_77568_93106_r# a_77568_93106# 48.8651
RTUP14 a_82688_93106_r# a_82688_93106# 59.2809
RTUN8 a_76544_152994_r# a_76544_152994# 48.6644
RTUN22 a_90880_152994_r# a_90880_152994# 61.2958
RTUN14 a_82688_152994_r# a_82688_152994# 59.2298
RTUP0 a_68216_96594_r# a_68216_96594# 77.2846
RTUP12 a_80640_93106_r# a_80640_93106# 58.7835
RTUP19 a_87808_93106_r# a_87808_93106# 67.8144
.ends
