.subckt hs_protected_pad VSS VDD TERM_VCM TERM_ENABLE TERM_TRIM0 TERM_TRIM1 TERM_TRIM2 TERM_TRIM3 VBIAS RX_P RX_N PAD_P PAD_N
XPHYSICAL ESD_RAIL VSS VDD TERM_VCM TERM_ENABLE TERM_TRIM0 TERM_TRIM1 TERM_TRIM2 TERM_TRIM3 VBIAS RX_P RX_N PAD_P PAD_N pad_hspad_flat
.ends hs_protected_pad
* NGSPICE file created from pad_hspad_flat.ext - technology: gf180mcuD

.subckt pad_hspad_flat ESD_RAIL VSS VDD TERM_VCM TERM_ENABLE TERM_TRIM0 TERM_TRIM1 TERM_TRIM2 TERM_TRIM3 VBIAS RX_P RX_N PAD_P PAD_N
X0 a_74812_152046# TERM_ENABLE TERM_VCM__N6 VSS nfet_06v0 ad=8.8p pd=40.88u as=8.8p ps=40.88u w=20u l=0.7u
X1 ESD_RAIL a_1852_148519# VSS VSS nfet_06v0 ad=13.936p pd=54.12u as=13.936p ps=54.12u w=53.6u l=0.7u
X2 ESD_RAIL a_1852_148519# VSS VSS nfet_06v0 ad=13.936p pd=54.12u as=13.936p ps=54.12u w=53.6u l=0.7u
X3 ESD_RAIL a_2245_90628# VSS VSS nfet_06v0 ad=22p pd=0.10088m as=13p ps=50.52u w=50u l=0.7u
X4 a_1005_133505# a_13878_133225# ESD_RAIL ppolyf_u r_width=0.8u r_length=63.855u
X5 a_72676_152046# TERM_ENABLE TERM_VCM__N4 VSS nfet_06v0 ad=8.8p pd=40.88u as=8.8p ps=40.88u w=20u l=0.7u
X6 ESD_RAIL a_1852_148519# VSS VSS nfet_06v0 ad=13.936p pd=54.12u as=23.584p ps=0.10808m w=53.6u l=0.7u
X7 ESD_RAIL a_1852_148519# VSS VSS nfet_06v0 ad=13.936p pd=54.12u as=13.936p ps=54.12u w=53.6u l=0.7u
X8 VSS a_1852_148519# ESD_RAIL VSS nfet_06v0 ad=13.936p pd=54.12u as=13.936p ps=54.12u w=53.6u l=0.7u
X9 RX_N__dev VBIAS VSS ppolyf_u_1k r_width=1u r_length=40u
X10 VSS a_2245_90628# ESD_RAIL VSS nfet_06v0 ad=13p pd=50.52u as=13p ps=50.52u w=50u l=0.7u
X11 VSS a_1852_148519# ESD_RAIL VSS nfet_06v0 ad=13.936p pd=54.12u as=13.936p ps=54.12u w=53.6u l=0.7u
X12 ESD_RAIL a_1852_148519# VSS VSS nfet_06v0 ad=13.936p pd=54.12u as=13.936p ps=54.12u w=53.6u l=0.7u
D0 PAD_P__dio ESD_RAIL diode_pd2nw_06v0 pj=51.8u area=22.5p
X13 VSS a_1852_148519# ESD_RAIL VSS nfet_06v0 ad=13.936p pd=54.12u as=13.936p ps=54.12u w=53.6u l=0.7u
X14 ESD_RAIL a_2245_90628# VSS VSS nfet_06v0 ad=22p pd=0.10088m as=13p ps=50.52u w=50u l=0.7u
X15 a_80152_152846# TERM_TRIM1 TERM_VCM__N11 VSS nfet_06v0 ad=5.28p pd=24.88u as=5.28p ps=24.88u w=12u l=0.7u
X16 PAD_P__h16 a_85492_91054_r# VSS ppolyf_u r_width=2u r_length=1u
X17 PAD_P__h18 a_87628_91054_r# VSS ppolyf_u r_width=2u r_length=1u
X18 a_75880_90254# TERM_ENABLE TERM_VCM__P7 VSS nfet_06v0 ad=8.8p pd=40.88u as=8.8p ps=40.88u w=20u l=0.7u
X19 ESD_RAIL a_4789_117064# a_2245_90628# ESD_RAIL pfet_06v0 ad=1.3p pd=5.52u as=1.3p ps=5.52u w=5u l=0.7u
X20 a_82288_91054# TERM_TRIM2 TERM_VCM__P13 VSS nfet_06v0 ad=5.28p pd=24.88u as=5.28p ps=24.88u w=12u l=0.7u
X21 ESD_RAIL a_1852_148519# VSS VSS nfet_06v0 ad=13.936p pd=54.12u as=13.936p ps=54.12u w=53.6u l=0.7u
X22 ESD_RAIL a_4789_117064# a_2245_90628# ESD_RAIL pfet_06v0 ad=1.3p pd=5.52u as=1.3p ps=5.52u w=5u l=0.7u
X23 ESD_RAIL a_1852_148519# VSS VSS nfet_06v0 ad=13.936p pd=54.12u as=13.936p ps=54.12u w=53.6u l=0.7u
X24 RX_P__mim PAD_P__mim cap_mim_2f0_m4m5_noshield c_width=35u c_length=35u
X25 ESD_RAIL a_2245_90628# VSS VSS nfet_06v0 ad=13p pd=50.52u as=13p ps=50.52u w=50u l=0.7u
X26 a_91900_152846_r# PAD_N__h22 VSS ppolyf_u r_width=2u r_length=1u
X27 VSS a_1852_148519# ESD_RAIL VSS nfet_06v0 ad=13.936p pd=54.12u as=13.936p ps=54.12u w=53.6u l=0.7u
X28 ESD_RAIL a_13878_134345# ESD_RAIL ppolyf_u r_width=0.8u r_length=63.855u
X29 ESD_RAIL a_1852_148519# VSS VSS nfet_06v0 ad=13.936p pd=54.12u as=13.936p ps=54.12u w=53.6u l=0.7u
X30 VSS a_1852_148519# ESD_RAIL VSS nfet_06v0 ad=13.936p pd=54.12u as=13.936p ps=54.12u w=53.6u l=0.7u
X31 ESD_RAIL a_1852_148519# VSS VSS nfet_06v0 ad=13.936p pd=54.12u as=13.936p ps=54.12u w=53.6u l=0.7u
X32 ESD_RAIL a_1852_148519# VSS VSS nfet_06v0 ad=13.936p pd=54.12u as=13.936p ps=54.12u w=53.6u l=0.7u
D1 VSS PAD_P__dio diode_nd2ps_06v0 pj=51.8u area=22.5p
X33 a_83356_152846_r# PAD_N__h14 VSS ppolyf_u r_width=2u r_length=1u
X34 VSS a_1852_148519# ESD_RAIL VSS nfet_06v0 ad=13.936p pd=54.12u as=13.936p ps=54.12u w=53.6u l=0.7u
X35 a_73744_152046_r# PAD_N__h5 VSS ppolyf_u r_width=2u r_length=2.6u
X36 ESD_RAIL a_2245_90628# VSS VSS nfet_06v0 ad=13p pd=50.52u as=13p ps=50.52u w=50u l=0.7u
X37 a_79084_152846# TERM_TRIM0 TERM_VCM__N10 VSS nfet_06v0 ad=5.28p pd=24.88u as=5.28p ps=24.88u w=12u l=0.7u
X38 ESD_RAIL a_1852_148519# VSS VSS nfet_06v0 ad=13.936p pd=54.12u as=13.936p ps=54.12u w=53.6u l=0.7u
X39 a_71608_152046# TERM_ENABLE TERM_VCM__N3 VSS nfet_06v0 ad=8.8p pd=40.88u as=8.8p ps=40.88u w=20u l=0.7u
X40 VSS a_1852_148519# ESD_RAIL VSS nfet_06v0 ad=13.936p pd=54.12u as=13.936p ps=54.12u w=53.6u l=0.7u
X41 VSS a_2245_90628# ESD_RAIL VSS nfet_06v0 ad=13p pd=50.52u as=22p ps=0.10088m w=50u l=0.7u
X42 VSS a_1852_148519# ESD_RAIL VSS nfet_06v0 ad=23.584p pd=0.10808m as=13.936p ps=54.12u w=53.6u l=0.7u
X43 VSS a_2245_90628# ESD_RAIL VSS nfet_06v0 ad=13p pd=50.52u as=13p ps=50.52u w=50u l=0.7u
X44 VSS a_1852_148519# ESD_RAIL VSS nfet_06v0 ad=13.936p pd=54.12u as=13.936p ps=54.12u w=53.6u l=0.7u
X45 VSS a_1852_148519# ESD_RAIL VSS nfet_06v0 ad=13.936p pd=54.12u as=13.936p ps=54.12u w=53.6u l=0.7u
X46 VSS a_1852_148519# ESD_RAIL VSS nfet_06v0 ad=23.584p pd=0.10808m as=13.936p ps=54.12u w=53.6u l=0.7u
X47 VSS a_2245_90628# ESD_RAIL VSS nfet_06v0 ad=13p pd=50.52u as=13p ps=50.52u w=50u l=0.7u
X48 a_81220_152846# TERM_TRIM1 TERM_VCM__N12 VSS nfet_06v0 ad=5.28p pd=24.88u as=5.28p ps=24.88u w=12u l=0.7u
X49 ESD_RAIL a_1852_148519# VSS VSS nfet_06v0 ad=13.936p pd=54.12u as=13.936p ps=54.12u w=53.6u l=0.7u
X50 a_75880_152046_r# PAD_N__h7 VSS ppolyf_u r_width=2u r_length=2.6u
X51 ESD_RAIL a_1852_148519# VSS VSS nfet_06v0 ad=13.936p pd=54.12u as=13.936p ps=54.12u w=53.6u l=0.7u
X52 ESD_RAIL a_2245_90628# VSS VSS nfet_06v0 ad=13p pd=50.52u as=13p ps=50.52u w=50u l=0.7u
X53 a_92968_91054# TERM_TRIM3 TERM_VCM__P23 VSS nfet_06v0 ad=5.28p pd=24.88u as=5.28p ps=24.88u w=12u l=0.7u
X54 VSS a_1852_148519# ESD_RAIL VSS nfet_06v0 ad=13.936p pd=54.12u as=13.936p ps=54.12u w=53.6u l=0.7u
D2 PAD_N__dio ESD_RAIL diode_pd2nw_06v0 pj=51.8u area=22.5p
X55 VSS a_1852_148519# ESD_RAIL VSS nfet_06v0 ad=13.936p pd=54.12u as=13.936p ps=54.12u w=53.6u l=0.7u
X56 ESD_RAIL a_1852_148519# VSS VSS nfet_06v0 ad=13.936p pd=54.12u as=13.936p ps=54.12u w=53.6u l=0.7u
X57 ESD_RAIL a_1852_148519# VSS VSS nfet_06v0 ad=13.936p pd=54.12u as=13.936p ps=54.12u w=53.6u l=0.7u
X58 ESD_RAIL a_1852_148519# VSS VSS nfet_06v0 ad=13.936p pd=54.12u as=13.936p ps=54.12u w=53.6u l=0.7u
X59 a_89764_91054# TERM_TRIM3 TERM_VCM__P20 VSS nfet_06v0 ad=5.28p pd=24.88u as=5.28p ps=24.88u w=12u l=0.7u
X60 VSS a_1852_148519# ESD_RAIL VSS nfet_06v0 ad=13.936p pd=54.12u as=13.936p ps=54.12u w=53.6u l=0.7u
X61 VSS a_1852_148519# ESD_RAIL VSS nfet_06v0 ad=13.936p pd=54.12u as=13.936p ps=54.12u w=53.6u l=0.7u
X62 VSS a_1852_148519# ESD_RAIL VSS nfet_06v0 ad=23.584p pd=0.10808m as=13.936p ps=54.12u w=53.6u l=0.7u
X63 ESD_RAIL a_1852_148519# VSS VSS nfet_06v0 ad=13.936p pd=54.12u as=13.936p ps=54.12u w=53.6u l=0.7u
X64 ESD_RAIL a_2245_90628# VSS VSS nfet_06v0 ad=13p pd=50.52u as=13p ps=50.52u w=50u l=0.7u
X65 ESD_RAIL a_1005_131545# a_3813_117064# ESD_RAIL pfet_06v0 ad=1.3p pd=5.52u as=1.3p ps=5.52u w=5u l=0.7u
D3 VSS PAD_P__dio diode_nd2ps_06v0 pj=51.8u area=22.5p
D4 PAD_N__dio ESD_RAIL diode_pd2nw_06v0 pj=51.8u area=22.5p
X66 a_84424_91054# TERM_TRIM2 TERM_VCM__P15 VSS nfet_06v0 ad=5.28p pd=24.88u as=5.28p ps=24.88u w=12u l=0.7u
X67 ESD_RAIL a_1852_148519# VSS VSS nfet_06v0 ad=13.936p pd=54.12u as=13.936p ps=54.12u w=53.6u l=0.7u
X68 ESD_RAIL a_1852_148519# VSS VSS nfet_06v0 ad=13.936p pd=54.12u as=13.936p ps=54.12u w=53.6u l=0.7u
X69 VSS a_1852_148519# ESD_RAIL VSS nfet_06v0 ad=13.936p pd=54.12u as=13.936p ps=54.12u w=53.6u l=0.7u
X70 PAD_P__h17 a_86560_91054_r# VSS ppolyf_u r_width=2u r_length=1u
X71 VSS a_1852_148519# ESD_RAIL VSS nfet_06v0 ad=13.936p pd=54.12u as=13.936p ps=54.12u w=53.6u l=0.7u
X72 ESD_RAIL a_1852_148519# VSS VSS nfet_06v0 ad=13.936p pd=54.12u as=13.936p ps=54.12u w=53.6u l=0.7u
X73 ESD_RAIL a_1852_148519# VSS VSS nfet_06v0 ad=13.936p pd=54.12u as=13.936p ps=54.12u w=53.6u l=0.7u
X74 PAD_P__h3 a_71608_90254_r# VSS ppolyf_u r_width=2u r_length=2.6u
X75 a_89764_152846# TERM_TRIM3 TERM_VCM__N20 VSS nfet_06v0 ad=5.28p pd=24.88u as=5.28p ps=24.88u w=12u l=0.7u
X76 VSS a_2245_90628# ESD_RAIL VSS nfet_06v0 ad=13p pd=50.52u as=13p ps=50.52u w=50u l=0.7u
X77 PAD_P__h24 a_94036_91054_r# VSS ppolyf_u r_width=2u r_length=1u
D5 PAD_N__dio ESD_RAIL diode_pd2nw_06v0 pj=51.8u area=22.5p
X78 PAD_P__h9 a_78016_90254_r# VSS ppolyf_u r_width=2u r_length=2.6u
X79 VSS a_2245_90628# ESD_RAIL VSS nfet_06v0 ad=13p pd=50.52u as=13p ps=50.52u w=50u l=0.7u
X80 VSS a_2245_90628# ESD_RAIL VSS nfet_06v0 ad=13p pd=50.52u as=13p ps=50.52u w=50u l=0.7u
X81 VSS a_1852_148519# ESD_RAIL VSS nfet_06v0 ad=13.936p pd=54.12u as=13.936p ps=54.12u w=53.6u l=0.7u
X82 ESD_RAIL a_1852_148519# VSS VSS nfet_06v0 ad=13.936p pd=54.12u as=13.936p ps=54.12u w=53.6u l=0.7u
X83 VSS a_1852_148519# ESD_RAIL VSS nfet_06v0 ad=13.936p pd=54.12u as=13.936p ps=54.12u w=53.6u l=0.7u
X84 a_79084_91054# TERM_TRIM0 TERM_VCM__P10 VSS nfet_06v0 ad=5.28p pd=24.88u as=5.28p ps=24.88u w=12u l=0.7u
X85 ESD_RAIL a_2245_90628# VSS VSS nfet_06v0 ad=13p pd=50.52u as=13p ps=50.52u w=50u l=0.7u
X86 VSS a_1852_148519# ESD_RAIL VSS nfet_06v0 ad=13.936p pd=54.12u as=13.936p ps=54.12u w=53.6u l=0.7u
X87 ESD_RAIL a_1852_148519# VSS VSS nfet_06v0 ad=13.936p pd=54.12u as=13.936p ps=54.12u w=53.6u l=0.7u
X88 ESD_RAIL a_1852_148519# VSS VSS nfet_06v0 ad=13.936p pd=54.12u as=13.936p ps=54.12u w=53.6u l=0.7u
X89 ESD_RAIL a_2245_90628# VSS VSS nfet_06v0 ad=13p pd=50.52u as=13p ps=50.52u w=50u l=0.7u
X90 ESD_RAIL a_2245_90628# VSS VSS nfet_06v0 ad=13p pd=50.52u as=13p ps=50.52u w=50u l=0.7u
X91 a_2245_90628# a_4789_117064# ESD_RAIL ESD_RAIL pfet_06v0 ad=1.3p pd=5.52u as=1.3p ps=5.52u w=5u l=0.7u
X92 ESD_RAIL a_1852_148519# VSS VSS nfet_06v0 ad=13.936p pd=54.12u as=13.936p ps=54.12u w=53.6u l=0.7u
X93 ESD_RAIL a_1852_148519# VSS VSS nfet_06v0 ad=13.936p pd=54.12u as=23.584p ps=0.10808m w=53.6u l=0.7u
X94 ESD_RAIL a_1852_148519# VSS VSS nfet_06v0 ad=13.936p pd=54.12u as=13.936p ps=54.12u w=53.6u l=0.7u
D6 PAD_N__dio ESD_RAIL diode_pd2nw_06v0 pj=51.8u area=22.5p
X95 a_88696_152846_r# PAD_N__h19 VSS ppolyf_u r_width=2u r_length=1u
X96 VSS a_1852_148519# ESD_RAIL VSS nfet_06v0 ad=13.936p pd=54.12u as=13.936p ps=54.12u w=53.6u l=0.7u
X97 a_2245_90628# a_4789_117064# ESD_RAIL ESD_RAIL pfet_06v0 ad=1.3p pd=5.52u as=1.3p ps=5.52u w=5u l=0.7u
X98 VSS a_1852_148519# ESD_RAIL VSS nfet_06v0 ad=13.936p pd=54.12u as=13.936p ps=54.12u w=53.6u l=0.7u
X99 ESD_RAIL a_2245_90628# VSS VSS nfet_06v0 ad=13p pd=50.52u as=13p ps=50.52u w=50u l=0.7u
X100 a_78016_152046_r# PAD_N__h9 VSS ppolyf_u r_width=2u r_length=2.6u
X101 ESD_RAIL a_4789_117064# a_2245_90628# ESD_RAIL pfet_06v0 ad=1.3p pd=5.52u as=1.3p ps=5.52u w=5u l=0.7u
X102 a_80152_152846_r# PAD_N__h11 VSS ppolyf_u r_width=2u r_length=1u
X103 a_1005_132385# a_13878_132105# ESD_RAIL ppolyf_u r_width=0.8u r_length=63.855u
X104 ESD_RAIL a_1852_148519# VSS VSS nfet_06v0 ad=13.936p pd=54.12u as=13.936p ps=54.12u w=53.6u l=0.7u
X105 ESD_RAIL w_71178_112088# VSS ppolyf_u_1k_6p0 r_width=1u r_length=0.47474m
X106 a_69448_149284_r# PAD_N__h1 VSS ppolyf_u r_width=2u r_length=2.6u
X107 a_88696_152846# TERM_TRIM3 TERM_VCM__N19 VSS nfet_06v0 ad=5.28p pd=24.88u as=5.28p ps=24.88u w=12u l=0.7u
X108 ESD_RAIL a_1852_148519# VSS VSS nfet_06v0 ad=13.936p pd=54.12u as=13.936p ps=54.12u w=53.6u l=0.7u
X109 VSS a_1852_148519# ESD_RAIL VSS nfet_06v0 ad=13.936p pd=54.12u as=13.936p ps=54.12u w=53.6u l=0.7u
X110 VSS a_2245_90628# ESD_RAIL VSS nfet_06v0 ad=13p pd=50.52u as=13p ps=50.52u w=50u l=0.7u
X111 VSS a_1852_148519# ESD_RAIL VSS nfet_06v0 ad=13.936p pd=54.12u as=13.936p ps=54.12u w=53.6u l=0.7u
X112 VSS a_1852_148519# ESD_RAIL VSS nfet_06v0 ad=13.936p pd=54.12u as=13.936p ps=54.12u w=53.6u l=0.7u
X113 PAD_P__h22 a_91900_91054_r# VSS ppolyf_u r_width=2u r_length=1u
X114 ESD_RAIL a_4789_117064# a_2245_90628# ESD_RAIL pfet_06v0 ad=1.3p pd=5.52u as=1.3p ps=5.52u w=5u l=0.7u
X115 ESD_RAIL a_1852_148519# VSS VSS nfet_06v0 ad=13.936p pd=54.12u as=13.936p ps=54.12u w=53.6u l=0.7u
X116 a_2245_90628# a_4789_117064# VSS VSS nfet_06v0 ad=1.3p pd=5.52u as=1.3p ps=5.52u w=5u l=0.7u
X117 PAD_P__h15 a_84424_91054_r# VSS ppolyf_u r_width=2u r_length=1u
X118 a_2245_90628# a_4789_117064# ESD_RAIL ESD_RAIL pfet_06v0 ad=1.3p pd=5.52u as=1.3p ps=5.52u w=5u l=0.7u
X119 PAD_P__h0 a_68216_96914_r# VSS ppolyf_u r_width=2u r_length=2.6u
X120 ESD_RAIL a_1005_131545# a_3813_117064# ESD_RAIL pfet_06v0 ad=1.3p pd=5.52u as=1.3p ps=5.52u w=5u l=0.7u
X121 ESD_RAIL a_1852_148519# VSS VSS nfet_06v0 ad=13.936p pd=54.12u as=13.936p ps=54.12u w=53.6u l=0.7u
X122 VSS a_1852_148519# ESD_RAIL VSS nfet_06v0 ad=13.936p pd=54.12u as=13.936p ps=54.12u w=53.6u l=0.7u
X123 VSS a_1852_148519# ESD_RAIL VSS nfet_06v0 ad=13.936p pd=54.12u as=13.936p ps=54.12u w=53.6u l=0.7u
X124 VSS a_2245_90628# ESD_RAIL VSS nfet_06v0 ad=13p pd=50.52u as=13p ps=50.52u w=50u l=0.7u
X125 ESD_RAIL a_1852_148519# VSS VSS nfet_06v0 ad=13.936p pd=54.12u as=23.584p ps=0.10808m w=53.6u l=0.7u
X126 ESD_RAIL a_1852_148519# VSS VSS nfet_06v0 ad=13.936p pd=54.12u as=23.584p ps=0.10808m w=53.6u l=0.7u
X127 ESD_RAIL a_1852_148519# VSS VSS nfet_06v0 ad=13.936p pd=54.12u as=13.936p ps=54.12u w=53.6u l=0.7u
X128 a_2245_90628# a_4789_117064# ESD_RAIL ESD_RAIL pfet_06v0 ad=1.3p pd=5.52u as=1.3p ps=5.52u w=5u l=0.7u
X129 VSS a_1852_148519# ESD_RAIL VSS nfet_06v0 ad=23.584p pd=0.10808m as=13.936p ps=54.12u w=53.6u l=0.7u
X130 a_83356_91054# TERM_TRIM2 TERM_VCM__P14 VSS nfet_06v0 ad=5.28p pd=24.88u as=5.28p ps=24.88u w=12u l=0.7u
X131 VSS a_1852_148519# ESD_RAIL VSS nfet_06v0 ad=13.936p pd=54.12u as=13.936p ps=54.12u w=53.6u l=0.7u
X132 VSS a_1852_148519# ESD_RAIL VSS nfet_06v0 ad=13.936p pd=54.12u as=13.936p ps=54.12u w=53.6u l=0.7u
X133 ESD_RAIL a_2245_90628# VSS VSS nfet_06v0 ad=13p pd=50.52u as=13p ps=50.52u w=50u l=0.7u
X134 a_81220_152846_r# PAD_N__h12 VSS ppolyf_u r_width=2u r_length=1u
X135 a_1005_131545# VSS cap_mim_2f0_m4m5_noshield c_width=14u c_length=14u
X136 ESD_RAIL a_2245_90628# VSS VSS nfet_06v0 ad=13p pd=50.52u as=13p ps=50.52u w=50u l=0.7u
X137 ESD_RAIL a_1852_148519# VSS VSS nfet_06v0 ad=13.936p pd=54.12u as=13.936p ps=54.12u w=53.6u l=0.7u
X138 VSS a_1852_148519# ESD_RAIL VSS nfet_06v0 ad=13.936p pd=54.12u as=13.936p ps=54.12u w=53.6u l=0.7u
X139 a_87628_152846# TERM_TRIM3 TERM_VCM__N18 VSS nfet_06v0 ad=5.28p pd=24.88u as=5.28p ps=24.88u w=12u l=0.7u
X140 ESD_RAIL a_1852_148519# VSS VSS nfet_06v0 ad=13.936p pd=54.12u as=13.936p ps=54.12u w=53.6u l=0.7u
X141 a_1005_131825# a_13878_132105# ESD_RAIL ppolyf_u r_width=0.8u r_length=63.855u
D7 PAD_P__dio ESD_RAIL diode_pd2nw_06v0 pj=51.8u area=22.5p
X142 VSS a_1852_148519# ESD_RAIL VSS nfet_06v0 ad=23.584p pd=0.10808m as=13.936p ps=54.12u w=53.6u l=0.7u
X143 ESD_RAIL a_2245_90628# VSS VSS nfet_06v0 ad=13p pd=50.52u as=13p ps=50.52u w=50u l=0.7u
X144 ESD_RAIL a_2245_90628# VSS VSS nfet_06v0 ad=13p pd=50.52u as=13p ps=50.52u w=50u l=0.7u
X145 PAD_P__h13 a_82288_91054_r# VSS ppolyf_u r_width=2u r_length=1u
X146 a_2245_90628# a_4789_117064# ESD_RAIL ESD_RAIL pfet_06v0 ad=1.3p pd=5.52u as=1.3p ps=5.52u w=5u l=0.7u
X147 ESD_RAIL a_2245_90628# VSS VSS nfet_06v0 ad=13p pd=50.52u as=13p ps=50.52u w=50u l=0.7u
X148 VSS a_2245_90628# ESD_RAIL VSS nfet_06v0 ad=13p pd=50.52u as=13p ps=50.52u w=50u l=0.7u
X149 VSS a_1852_148519# ESD_RAIL VSS nfet_06v0 ad=13.936p pd=54.12u as=13.936p ps=54.12u w=53.6u l=0.7u
X150 ESD_RAIL a_1852_148519# VSS VSS nfet_06v0 ad=13.936p pd=54.12u as=13.936p ps=54.12u w=53.6u l=0.7u
X151 ESD_RAIL a_1852_148519# VSS VSS nfet_06v0 ad=13.936p pd=54.12u as=13.936p ps=54.12u w=53.6u l=0.7u
X152 VSS a_2245_90628# ESD_RAIL VSS nfet_06v0 ad=13p pd=50.52u as=13p ps=50.52u w=50u l=0.7u
X153 a_2245_90628# a_4789_117064# ESD_RAIL ESD_RAIL pfet_06v0 ad=1.3p pd=5.52u as=1.3p ps=5.52u w=5u l=0.7u
X154 VSS a_1852_148519# ESD_RAIL VSS nfet_06v0 ad=13.936p pd=54.12u as=13.936p ps=54.12u w=53.6u l=0.7u
X155 PAD_P__h20 a_89764_91054_r# VSS ppolyf_u r_width=2u r_length=1u
X156 VSS a_4789_117064# a_2245_90628# VSS nfet_06v0 ad=2.2p pd=10.88u as=1.3p ps=5.52u w=5u l=0.7u
X157 ESD_RAIL a_4789_117064# a_2245_90628# ESD_RAIL pfet_06v0 ad=1.3p pd=5.52u as=1.3p ps=5.52u w=5u l=0.7u
X158 ESD_RAIL a_2245_90628# VSS VSS nfet_06v0 ad=22p pd=0.10088m as=13p ps=50.52u w=50u l=0.7u
D8 VSS PAD_N__dio diode_nd2ps_06v0 pj=51.8u area=22.5p
X159 a_1005_132945# a_13878_133225# ESD_RAIL ppolyf_u r_width=0.8u r_length=63.855u
X160 ESD_RAIL a_1852_148519# VSS VSS nfet_06v0 ad=13.936p pd=54.12u as=13.936p ps=54.12u w=53.6u l=0.7u
X161 ESD_RAIL a_1852_148519# VSS VSS nfet_06v0 ad=13.936p pd=54.12u as=13.936p ps=54.12u w=53.6u l=0.7u
X162 ESD_RAIL a_1852_148519# VSS VSS nfet_06v0 ad=13.936p pd=54.12u as=13.936p ps=54.12u w=53.6u l=0.7u
X163 VSS a_1852_148519# ESD_RAIL VSS nfet_06v0 ad=13.936p pd=54.12u as=13.936p ps=54.12u w=53.6u l=0.7u
X164 ESD_RAIL a_4789_117064# a_2245_90628# ESD_RAIL pfet_06v0 ad=1.3p pd=5.52u as=1.3p ps=5.52u w=5u l=0.7u
X165 ESD_RAIL a_1852_148519# VSS VSS nfet_06v0 ad=13.936p pd=54.12u as=13.936p ps=54.12u w=53.6u l=0.7u
X166 a_2245_90628# a_4789_117064# VSS VSS nfet_06v0 ad=1.3p pd=5.52u as=1.3p ps=5.52u w=5u l=0.7u
X167 a_2245_90628# a_4789_117064# ESD_RAIL ESD_RAIL pfet_06v0 ad=1.3p pd=5.52u as=2.2p ps=10.88u w=5u l=0.7u
X168 a_3813_117064# a_1005_131545# VSS VSS nfet_06v0 ad=2.2p pd=10.88u as=2.2p ps=10.88u w=5u l=0.7u
X169 a_85492_91054# TERM_TRIM2 TERM_VCM__P16 VSS nfet_06v0 ad=5.28p pd=24.88u as=5.28p ps=24.88u w=12u l=0.7u
X170 a_92968_152846# TERM_TRIM3 TERM_VCM__N23 VSS nfet_06v0 ad=5.28p pd=24.88u as=5.28p ps=24.88u w=12u l=0.7u
X171 PAD_P__h2 a_70540_90254_r# VSS ppolyf_u r_width=2u r_length=2.6u
X172 VSS a_1852_148519# ESD_RAIL VSS nfet_06v0 ad=13.936p pd=54.12u as=13.936p ps=54.12u w=53.6u l=0.7u
X173 VSS a_1852_148519# ESD_RAIL VSS nfet_06v0 ad=13.936p pd=54.12u as=13.936p ps=54.12u w=53.6u l=0.7u
D9 PAD_P__dio ESD_RAIL diode_pd2nw_06v0 pj=51.8u area=22.5p
X174 VSS a_1852_148519# ESD_RAIL VSS nfet_06v0 ad=13.936p pd=54.12u as=13.936p ps=54.12u w=53.6u l=0.7u
X175 VSS a_1852_148519# ESD_RAIL VSS nfet_06v0 ad=13.936p pd=54.12u as=13.936p ps=54.12u w=53.6u l=0.7u
X176 a_74812_152046_r# PAD_N__h6 VSS ppolyf_u r_width=2u r_length=2.6u
X177 ESD_RAIL a_2245_90628# VSS VSS nfet_06v0 ad=13p pd=50.52u as=13p ps=50.52u w=50u l=0.7u
X178 a_2245_90628# a_4789_117064# VSS VSS nfet_06v0 ad=1.3p pd=5.52u as=1.3p ps=5.52u w=5u l=0.7u
X179 VDD w_71178_112088# w_71178_112088# w_71178_112088# pfet_06v0 ad=1.76p pd=8.88u as=1.76p ps=8.88u w=4u l=0.55u
X180 VSS a_3813_117064# a_4789_117064# VSS nfet_06v0 ad=1.3p pd=5.52u as=1.3p ps=5.52u w=5u l=0.7u
X181 a_2245_90628# a_4789_117064# ESD_RAIL ESD_RAIL pfet_06v0 ad=1.3p pd=5.52u as=1.3p ps=5.52u w=5u l=0.7u
X182 ESD_RAIL a_1852_148519# VSS VSS nfet_06v0 ad=13.936p pd=54.12u as=13.936p ps=54.12u w=53.6u l=0.7u
X183 PAD_P__h8 a_76948_90254_r# VSS ppolyf_u r_width=2u r_length=2.6u
X184 VSS a_1852_148519# ESD_RAIL VSS nfet_06v0 ad=13.936p pd=54.12u as=13.936p ps=54.12u w=53.6u l=0.7u
X185 a_70540_152046# TERM_ENABLE TERM_VCM__N2 VSS nfet_06v0 ad=8.8p pd=40.88u as=8.8p ps=40.88u w=20u l=0.7u
X186 a_1005_134065# a_13878_134345# ESD_RAIL ppolyf_u r_width=0.8u r_length=63.855u
X187 ESD_RAIL a_2245_90628# VSS VSS nfet_06v0 ad=13p pd=50.52u as=13p ps=50.52u w=50u l=0.7u
X188 ESD_RAIL a_1852_148519# VSS VSS nfet_06v0 ad=13.936p pd=54.12u as=13.936p ps=54.12u w=53.6u l=0.7u
X189 ESD_RAIL a_2245_90628# VSS VSS nfet_06v0 ad=13p pd=50.52u as=13p ps=50.52u w=50u l=0.7u
X190 a_78016_90254# TERM_ENABLE TERM_VCM__P9 VSS nfet_06v0 ad=8.8p pd=40.88u as=8.8p ps=40.88u w=20u l=0.7u
X191 VSS a_3813_117064# a_4789_117064# VSS nfet_06v0 ad=1.3p pd=5.52u as=1.3p ps=5.52u w=5u l=0.7u
D10 PAD_P__dio ESD_RAIL diode_pd2nw_06v0 pj=51.8u area=22.5p
X192 PAD_P__h11 a_80152_91054_r# VSS ppolyf_u r_width=2u r_length=1u
X193 VSS a_1852_148519# ESD_RAIL VSS nfet_06v0 ad=13.936p pd=54.12u as=13.936p ps=54.12u w=53.6u l=0.7u
X194 ESD_RAIL a_1852_148519# VSS VSS nfet_06v0 ad=13.936p pd=54.12u as=13.936p ps=54.12u w=53.6u l=0.7u
X195 VSS a_2245_90628# ESD_RAIL VSS nfet_06v0 ad=13p pd=50.52u as=13p ps=50.52u w=50u l=0.7u
X196 RX_P__dev VSS VSS VSS nfet_06v0 ad=1.76p pd=8.88u as=1.76p ps=8.88u w=4u l=0.7u
X197 VSS a_1852_148519# ESD_RAIL VSS nfet_06v0 ad=13.936p pd=54.12u as=13.936p ps=54.12u w=53.6u l=0.7u
X198 a_70540_90254# TERM_ENABLE TERM_VCM__P2 VSS nfet_06v0 ad=8.8p pd=40.88u as=8.8p ps=40.88u w=20u l=0.7u
X199 ESD_RAIL a_2245_90628# VSS VSS nfet_06v0 ad=13p pd=50.52u as=13p ps=50.52u w=50u l=0.7u
X200 a_94036_152846# TERM_TRIM3 TERM_VCM__N24 VSS nfet_06v0 ad=5.28p pd=24.88u as=5.28p ps=24.88u w=12u l=0.7u
X201 ESD_RAIL a_1852_148519# VSS VSS nfet_06v0 ad=13.936p pd=54.12u as=13.936p ps=54.12u w=53.6u l=0.7u
X202 VSS a_1852_148519# ESD_RAIL VSS nfet_06v0 ad=13.936p pd=54.12u as=13.936p ps=54.12u w=53.6u l=0.7u
D11 VSS PAD_N__dio diode_nd2ps_06v0 pj=51.8u area=22.5p
X203 VSS a_1852_148519# ESD_RAIL VSS nfet_06v0 ad=13.936p pd=54.12u as=13.936p ps=54.12u w=53.6u l=0.7u
X204 a_90832_91054# TERM_TRIM3 TERM_VCM__P21 VSS nfet_06v0 ad=5.28p pd=24.88u as=5.28p ps=24.88u w=12u l=0.7u
X205 ESD_RAIL a_1852_148519# VSS VSS nfet_06v0 ad=13.936p pd=54.12u as=13.936p ps=54.12u w=53.6u l=0.7u
X206 a_2245_90628# a_4789_117064# ESD_RAIL ESD_RAIL pfet_06v0 ad=1.3p pd=5.52u as=1.3p ps=5.52u w=5u l=0.7u
X207 a_90832_152846_r# PAD_N__h21 VSS ppolyf_u r_width=2u r_length=1u
X208 VSS a_1852_148519# ESD_RAIL VSS nfet_06v0 ad=23.584p pd=0.10808m as=13.936p ps=54.12u w=53.6u l=0.7u
X209 ESD_RAIL a_2245_90628# VSS VSS nfet_06v0 ad=13p pd=50.52u as=13p ps=50.52u w=50u l=0.7u
X210 VSS a_1852_148519# ESD_RAIL VSS nfet_06v0 ad=13.936p pd=54.12u as=13.936p ps=54.12u w=53.6u l=0.7u
X211 VSS a_1852_148519# ESD_RAIL VSS nfet_06v0 ad=13.936p pd=54.12u as=13.936p ps=54.12u w=53.6u l=0.7u
X212 VSS a_1852_148519# ESD_RAIL VSS nfet_06v0 ad=13.936p pd=54.12u as=13.936p ps=54.12u w=53.6u l=0.7u
X213 VSS a_2245_90628# ESD_RAIL VSS nfet_06v0 ad=13p pd=50.52u as=13p ps=50.52u w=50u l=0.7u
D12 PAD_P__dio ESD_RAIL diode_pd2nw_06v0 pj=51.8u area=22.5p
X214 a_92968_152846_r# PAD_N__h23 VSS ppolyf_u r_width=2u r_length=1u
X215 ESD_RAIL a_2245_90628# VSS VSS nfet_06v0 ad=13p pd=50.52u as=13p ps=50.52u w=50u l=0.7u
X216 VSS a_1852_148519# ESD_RAIL VSS nfet_06v0 ad=23.584p pd=0.10808m as=13.936p ps=54.12u w=53.6u l=0.7u
X217 VSS a_1852_148519# ESD_RAIL VSS nfet_06v0 ad=23.584p pd=0.10808m as=13.936p ps=54.12u w=53.6u l=0.7u
X218 a_84424_152846_r# PAD_N__h15 VSS ppolyf_u r_width=2u r_length=1u
X219 ESD_RAIL a_1852_148519# VSS VSS nfet_06v0 ad=13.936p pd=54.12u as=13.936p ps=54.12u w=53.6u l=0.7u
X220 ESD_RAIL a_1852_148519# VSS VSS nfet_06v0 ad=13.936p pd=54.12u as=13.936p ps=54.12u w=53.6u l=0.7u
X221 VSS a_1852_148519# ESD_RAIL VSS nfet_06v0 ad=13.936p pd=54.12u as=13.936p ps=54.12u w=53.6u l=0.7u
X222 VSS a_2245_90628# ESD_RAIL VSS nfet_06v0 ad=13p pd=50.52u as=13p ps=50.52u w=50u l=0.7u
X223 VSS a_1852_148519# ESD_RAIL VSS nfet_06v0 ad=13.936p pd=54.12u as=13.936p ps=54.12u w=53.6u l=0.7u
X224 RX_P__mim PAD_P__mim cap_mim_2f0_m4m5_noshield c_width=35u c_length=35u
X225 ESD_RAIL a_1852_148519# VSS VSS nfet_06v0 ad=13.936p pd=54.12u as=13.936p ps=54.12u w=53.6u l=0.7u
X226 ESD_RAIL a_1852_148519# VSS VSS nfet_06v0 ad=13.936p pd=54.12u as=13.936p ps=54.12u w=53.6u l=0.7u
X227 VSS a_1852_148519# ESD_RAIL VSS nfet_06v0 ad=13.936p pd=54.12u as=13.936p ps=54.12u w=53.6u l=0.7u
X228 ESD_RAIL a_2245_90628# VSS VSS nfet_06v0 ad=13p pd=50.52u as=13p ps=50.52u w=50u l=0.7u
X229 VSS a_1852_148519# ESD_RAIL VSS nfet_06v0 ad=13.936p pd=54.12u as=13.936p ps=54.12u w=53.6u l=0.7u
X230 RX_P__dev VDD VDD VDD pfet_06v0 ad=1.76p pd=8.88u as=1.76p ps=8.88u w=4u l=0.55u
X231 a_76948_90254# TERM_ENABLE TERM_VCM__P8 VSS nfet_06v0 ad=8.8p pd=40.88u as=8.8p ps=40.88u w=20u l=0.7u
D13 PAD_N__dio ESD_RAIL diode_pd2nw_06v0 pj=51.8u area=22.5p
X232 ESD_RAIL a_2245_90628# VSS VSS nfet_06v0 ad=13p pd=50.52u as=13p ps=50.52u w=50u l=0.7u
X233 ESD_RAIL a_2245_90628# VSS VSS nfet_06v0 ad=13p pd=50.52u as=13p ps=50.52u w=50u l=0.7u
D14 VSS ESD_RAIL diode_nd2ps_06v0 pj=82u area=40p
X234 ESD_RAIL a_1852_148519# VSS VSS nfet_06v0 ad=13.936p pd=54.12u as=13.936p ps=54.12u w=53.6u l=0.7u
X235 PAD_P__h4 a_72676_90254_r# VSS ppolyf_u r_width=2u r_length=2.6u
X236 a_4789_117064# a_3813_117064# VSS VSS nfet_06v0 ad=1.3p pd=5.52u as=2.2p ps=10.88u w=5u l=0.7u
X237 ESD_RAIL a_1852_148519# VSS VSS nfet_06v0 ad=13.936p pd=54.12u as=13.936p ps=54.12u w=53.6u l=0.7u
X238 ESD_RAIL a_2245_90628# VSS VSS nfet_06v0 ad=13p pd=50.52u as=13p ps=50.52u w=50u l=0.7u
X239 a_71608_90254# TERM_ENABLE TERM_VCM__P3 VSS nfet_06v0 ad=8.8p pd=40.88u as=8.8p ps=40.88u w=20u l=0.7u
D15 VSS ESD_RAIL diode_nd2ps_06v0 pj=82u area=40p
X240 VSS a_2245_90628# ESD_RAIL VSS nfet_06v0 ad=13p pd=50.52u as=13p ps=50.52u w=50u l=0.7u
X241 VSS a_1852_148519# ESD_RAIL VSS nfet_06v0 ad=13.936p pd=54.12u as=13.936p ps=54.12u w=53.6u l=0.7u
X242 a_68216_96914# TERM_ENABLE TERM_VCM__P0 VSS nfet_06v0 ad=8.8p pd=40.88u as=8.8p ps=40.88u w=20u l=0.7u
D16 PAD_N__dio ESD_RAIL diode_pd2nw_06v0 pj=51.8u area=22.5p
X243 ESD_RAIL a_1852_148519# cap_mim_2f0_m4m5_noshield c_width=90u c_length=90u
X244 a_1005_131825# a_13878_131545# ESD_RAIL ppolyf_u r_width=0.8u r_length=63.855u
X245 ESD_RAIL a_1852_148519# VSS VSS nfet_06v0 ad=13.936p pd=54.12u as=13.936p ps=54.12u w=53.6u l=0.7u
X246 ESD_RAIL a_1852_148519# VSS VSS nfet_06v0 ad=13.936p pd=54.12u as=13.936p ps=54.12u w=53.6u l=0.7u
X247 VSS a_1852_148519# ESD_RAIL VSS nfet_06v0 ad=13.936p pd=54.12u as=13.936p ps=54.12u w=53.6u l=0.7u
X248 ESD_RAIL VSS cap_mim_2f0_m4m5_noshield c_width=31.6u c_length=31.6u
X249 a_70540_152046_r# PAD_N__h2 VSS ppolyf_u r_width=2u r_length=2.6u
X250 a_76948_152046# TERM_ENABLE TERM_VCM__N8 VSS nfet_06v0 ad=8.8p pd=40.88u as=8.8p ps=40.88u w=20u l=0.7u
X251 ESD_RAIL a_1852_148519# VSS VSS nfet_06v0 ad=13.936p pd=54.12u as=13.936p ps=54.12u w=53.6u l=0.7u
X252 VSS a_2245_90628# ESD_RAIL VSS nfet_06v0 ad=13p pd=50.52u as=22p ps=0.10088m w=50u l=0.7u
X253 a_86560_91054# TERM_TRIM3 TERM_VCM__P17 VSS nfet_06v0 ad=5.28p pd=24.88u as=5.28p ps=24.88u w=12u l=0.7u
D17 VSS PAD_P__dio diode_nd2ps_06v0 pj=51.8u area=22.5p
X254 a_86560_152846# TERM_TRIM3 TERM_VCM__N17 VSS nfet_06v0 ad=5.28p pd=24.88u as=5.28p ps=24.88u w=12u l=0.7u
X255 VSS a_2245_90628# ESD_RAIL VSS nfet_06v0 ad=13p pd=50.52u as=22p ps=0.10088m w=50u l=0.7u
X256 ESD_RAIL a_4789_117064# a_2245_90628# ESD_RAIL pfet_06v0 ad=1.3p pd=5.52u as=1.3p ps=5.52u w=5u l=0.7u
X257 a_81220_91054# TERM_TRIM1 TERM_VCM__P12 VSS nfet_06v0 ad=5.28p pd=24.88u as=5.28p ps=24.88u w=12u l=0.7u
X258 VSS a_1852_148519# ESD_RAIL VSS nfet_06v0 ad=13.936p pd=54.12u as=13.936p ps=54.12u w=53.6u l=0.7u
X259 ESD_RAIL a_1852_148519# VSS VSS nfet_06v0 ad=13.936p pd=54.12u as=13.936p ps=54.12u w=53.6u l=0.7u
X260 VBIAS RX_P__dev VSS ppolyf_u_1k r_width=1u r_length=40u
X261 ESD_RAIL a_1852_148519# VSS VSS nfet_06v0 ad=13.936p pd=54.12u as=13.936p ps=54.12u w=53.6u l=0.7u
X262 VSS a_1852_148519# ESD_RAIL VSS nfet_06v0 ad=13.936p pd=54.12u as=13.936p ps=54.12u w=53.6u l=0.7u
X263 VSS a_2245_90628# ESD_RAIL VSS nfet_06v0 ad=13p pd=50.52u as=13p ps=50.52u w=50u l=0.7u
X264 ESD_RAIL a_4789_117064# a_2245_90628# ESD_RAIL pfet_06v0 ad=1.3p pd=5.52u as=1.3p ps=5.52u w=5u l=0.7u
X265 ESD_RAIL a_2245_90628# VSS VSS nfet_06v0 ad=13p pd=50.52u as=13p ps=50.52u w=50u l=0.7u
X266 a_1005_132945# a_13878_132665# ESD_RAIL ppolyf_u r_width=0.8u r_length=63.855u
X267 ESD_RAIL a_1852_148519# VSS VSS nfet_06v0 ad=13.936p pd=54.12u as=13.936p ps=54.12u w=53.6u l=0.7u
X268 ESD_RAIL a_2245_90628# VSS VSS nfet_06v0 ad=13p pd=50.52u as=13p ps=50.52u w=50u l=0.7u
X269 ESD_RAIL a_1852_148519# VSS VSS nfet_06v0 ad=13.936p pd=54.12u as=13.936p ps=54.12u w=53.6u l=0.7u
D18 PAD_N__dio ESD_RAIL diode_pd2nw_06v0 pj=51.8u area=22.5p
X270 a_89764_152846_r# PAD_N__h20 VSS ppolyf_u r_width=2u r_length=1u
X271 a_78016_152046# TERM_ENABLE TERM_VCM__N9 VSS nfet_06v0 ad=8.8p pd=40.88u as=8.8p ps=40.88u w=20u l=0.7u
X272 VSS a_1852_148519# ESD_RAIL VSS nfet_06v0 ad=13.936p pd=54.12u as=13.936p ps=54.12u w=53.6u l=0.7u
X273 ESD_RAIL a_1852_148519# VSS VSS nfet_06v0 ad=13.936p pd=54.12u as=13.936p ps=54.12u w=53.6u l=0.7u
X274 ESD_RAIL a_1852_148519# VSS VSS nfet_06v0 ad=13.936p pd=54.12u as=13.936p ps=54.12u w=53.6u l=0.7u
X275 VSS a_1852_148519# ESD_RAIL VSS nfet_06v0 ad=23.584p pd=0.10808m as=13.936p ps=54.12u w=53.6u l=0.7u
X276 ESD_RAIL a_1852_148519# VSS VSS nfet_06v0 ad=13.936p pd=54.12u as=13.936p ps=54.12u w=53.6u l=0.7u
X277 VSS a_2245_90628# ESD_RAIL VSS nfet_06v0 ad=13p pd=50.52u as=13p ps=50.52u w=50u l=0.7u
X278 VSS a_1852_148519# ESD_RAIL VSS nfet_06v0 ad=13.936p pd=54.12u as=13.936p ps=54.12u w=53.6u l=0.7u
X279 VSS a_1852_148519# ESD_RAIL VSS nfet_06v0 ad=13.936p pd=54.12u as=13.936p ps=54.12u w=53.6u l=0.7u
X280 VSS a_1852_148519# ESD_RAIL VSS nfet_06v0 ad=13.936p pd=54.12u as=13.936p ps=54.12u w=53.6u l=0.7u
X281 VSS a_1852_148519# ESD_RAIL VSS nfet_06v0 ad=13.936p pd=54.12u as=13.936p ps=54.12u w=53.6u l=0.7u
X282 VSS a_1852_148519# ESD_RAIL VSS nfet_06v0 ad=13.936p pd=54.12u as=13.936p ps=54.12u w=53.6u l=0.7u
X283 ESD_RAIL a_1852_148519# VSS VSS nfet_06v0 ad=13.936p pd=54.12u as=13.936p ps=54.12u w=53.6u l=0.7u
X284 a_3813_117064# a_1005_131545# ESD_RAIL ESD_RAIL pfet_06v0 ad=1.3p pd=5.52u as=1.3p ps=5.52u w=5u l=0.7u
X285 a_85492_152846# TERM_TRIM2 TERM_VCM__N16 VSS nfet_06v0 ad=5.28p pd=24.88u as=5.28p ps=24.88u w=12u l=0.7u
X286 a_91900_91054# TERM_TRIM3 TERM_VCM__P22 VSS nfet_06v0 ad=5.28p pd=24.88u as=5.28p ps=24.88u w=12u l=0.7u
X287 a_83356_152846# TERM_TRIM2 TERM_VCM__N14 VSS nfet_06v0 ad=5.28p pd=24.88u as=5.28p ps=24.88u w=12u l=0.7u
X288 VSS a_1852_148519# ESD_RAIL VSS nfet_06v0 ad=23.584p pd=0.10808m as=13.936p ps=54.12u w=53.6u l=0.7u
D19 PAD_N__dio ESD_RAIL diode_pd2nw_06v0 pj=51.8u area=22.5p
X289 VSS ESD_RAIL VSS ppolyf_u_1k_6p0 r_width=1u r_length=9.98874m
X290 ESD_RAIL a_1852_148519# VSS VSS nfet_06v0 ad=13.936p pd=54.12u as=13.936p ps=54.12u w=53.6u l=0.7u
X291 ESD_RAIL a_1852_148519# VSS VSS nfet_06v0 ad=13.936p pd=54.12u as=13.936p ps=54.12u w=53.6u l=0.7u
X292 ESD_RAIL a_1852_148519# VSS VSS nfet_06v0 ad=13.936p pd=54.12u as=23.584p ps=0.10808m w=53.6u l=0.7u
X293 a_4789_117064# a_3813_117064# ESD_RAIL ESD_RAIL pfet_06v0 ad=2.2p pd=10.88u as=1.3p ps=5.52u w=5u l=0.7u
X294 ESD_RAIL a_1852_148519# VSS VSS nfet_06v0 ad=13.936p pd=54.12u as=23.584p ps=0.10808m w=53.6u l=0.7u
X295 ESD_RAIL a_2245_90628# VSS VSS nfet_06v0 ad=13p pd=50.52u as=13p ps=50.52u w=50u l=0.7u
X296 VSS a_1852_148519# ESD_RAIL VSS nfet_06v0 ad=13.936p pd=54.12u as=13.936p ps=54.12u w=53.6u l=0.7u
X297 ESD_RAIL a_1852_148519# VSS VSS nfet_06v0 ad=13.936p pd=54.12u as=13.936p ps=54.12u w=53.6u l=0.7u
X298 ESD_RAIL a_2245_90628# VSS VSS nfet_06v0 ad=13p pd=50.52u as=13p ps=50.52u w=50u l=0.7u
X299 ESD_RAIL a_1852_148519# VSS VSS nfet_06v0 ad=13.936p pd=54.12u as=13.936p ps=54.12u w=53.6u l=0.7u
X300 VSS a_1852_148519# ESD_RAIL VSS nfet_06v0 ad=13.936p pd=54.12u as=13.936p ps=54.12u w=53.6u l=0.7u
X301 a_82288_152846_r# PAD_N__h13 VSS ppolyf_u r_width=2u r_length=1u
X302 a_72676_152046_r# PAD_N__h4 VSS ppolyf_u r_width=2u r_length=2.6u
X303 RX_N__mim PAD_N__mim cap_mim_2f0_m4m5_noshield c_width=35u c_length=35u
X304 PAD_P__h21 a_90832_91054_r# VSS ppolyf_u r_width=2u r_length=1u
X305 a_2245_90628# a_4789_117064# ESD_RAIL ESD_RAIL pfet_06v0 ad=1.3p pd=5.52u as=1.3p ps=5.52u w=5u l=0.7u
X306 VSS a_1852_148519# ESD_RAIL VSS nfet_06v0 ad=13.936p pd=54.12u as=13.936p ps=54.12u w=53.6u l=0.7u
X307 VSS a_2245_90628# ESD_RAIL VSS nfet_06v0 ad=13p pd=50.52u as=13p ps=50.52u w=50u l=0.7u
X308 ESD_RAIL a_2245_90628# VSS VSS nfet_06v0 ad=13p pd=50.52u as=13p ps=50.52u w=50u l=0.7u
X309 VSS a_1852_148519# ESD_RAIL VSS nfet_06v0 ad=13.936p pd=54.12u as=13.936p ps=54.12u w=53.6u l=0.7u
X310 a_1005_134065# a_13878_133785# ESD_RAIL ppolyf_u r_width=0.8u r_length=63.855u
X311 a_84424_152846# TERM_TRIM2 TERM_VCM__N15 VSS nfet_06v0 ad=5.28p pd=24.88u as=5.28p ps=24.88u w=12u l=0.7u
X312 ESD_RAIL a_1852_148519# VSS VSS nfet_06v0 ad=13.936p pd=54.12u as=13.936p ps=54.12u w=53.6u l=0.7u
X313 ESD_RAIL a_1852_148519# VSS VSS nfet_06v0 ad=13.936p pd=54.12u as=13.936p ps=54.12u w=53.6u l=0.7u
X314 a_87628_91054# TERM_TRIM3 TERM_VCM__P18 VSS nfet_06v0 ad=5.28p pd=24.88u as=5.28p ps=24.88u w=12u l=0.7u
X315 ESD_RAIL a_1852_148519# VSS VSS nfet_06v0 ad=13.936p pd=54.12u as=13.936p ps=54.12u w=53.6u l=0.7u
X316 VSS a_2245_90628# ESD_RAIL VSS nfet_06v0 ad=13p pd=50.52u as=13p ps=50.52u w=50u l=0.7u
X317 a_82288_152846# TERM_TRIM2 TERM_VCM__N13 VSS nfet_06v0 ad=5.28p pd=24.88u as=5.28p ps=24.88u w=12u l=0.7u
X318 VSS a_2245_90628# ESD_RAIL VSS nfet_06v0 ad=13p pd=50.52u as=13p ps=50.52u w=50u l=0.7u
X319 ESD_RAIL a_4789_117064# a_2245_90628# ESD_RAIL pfet_06v0 ad=1.3p pd=5.52u as=1.3p ps=5.52u w=5u l=0.7u
X320 ESD_RAIL a_1852_148519# VSS VSS nfet_06v0 ad=13.936p pd=54.12u as=13.936p ps=54.12u w=53.6u l=0.7u
X321 PAD_P__h23 a_92968_91054_r# VSS ppolyf_u r_width=2u r_length=1u
X322 ESD_RAIL a_1852_148519# VSS VSS nfet_06v0 ad=13.936p pd=54.12u as=13.936p ps=54.12u w=53.6u l=0.7u
X323 VSS a_2245_90628# ESD_RAIL VSS nfet_06v0 ad=13p pd=50.52u as=13p ps=50.52u w=50u l=0.7u
X324 ESD_RAIL a_1852_148519# cap_mim_2f0_m4m5_noshield c_width=90u c_length=90u
D20 VSS ESD_RAIL diode_nd2ps_06v0 pj=82u area=40p
X325 a_80152_91054# TERM_TRIM1 TERM_VCM__P11 VSS nfet_06v0 ad=5.28p pd=24.88u as=5.28p ps=24.88u w=12u l=0.7u
X326 PAD_P__h1 a_69448_96914_r# VSS ppolyf_u r_width=2u r_length=2.6u
X327 ESD_RAIL a_3813_117064# a_4789_117064# ESD_RAIL pfet_06v0 ad=1.3p pd=5.52u as=1.3p ps=5.52u w=5u l=0.7u
X328 VSS a_1852_148519# ESD_RAIL VSS nfet_06v0 ad=13.936p pd=54.12u as=13.936p ps=54.12u w=53.6u l=0.7u
X329 VSS a_1852_148519# ESD_RAIL VSS nfet_06v0 ad=13.936p pd=54.12u as=13.936p ps=54.12u w=53.6u l=0.7u
X330 VSS a_1852_148519# ESD_RAIL VSS nfet_06v0 ad=13.936p pd=54.12u as=13.936p ps=54.12u w=53.6u l=0.7u
X331 ESD_RAIL a_1852_148519# VSS VSS nfet_06v0 ad=13.936p pd=54.12u as=13.936p ps=54.12u w=53.6u l=0.7u
X332 a_2245_90628# a_4789_117064# ESD_RAIL ESD_RAIL pfet_06v0 ad=1.3p pd=5.52u as=1.3p ps=5.52u w=5u l=0.7u
X333 ESD_RAIL a_1852_148519# VSS VSS nfet_06v0 ad=13.936p pd=54.12u as=13.936p ps=54.12u w=53.6u l=0.7u
X334 VSS a_2245_90628# ESD_RAIL VSS nfet_06v0 ad=13p pd=50.52u as=13p ps=50.52u w=50u l=0.7u
X335 VSS a_1852_148519# ESD_RAIL VSS nfet_06v0 ad=13.936p pd=54.12u as=13.936p ps=54.12u w=53.6u l=0.7u
X336 VSS a_1852_148519# ESD_RAIL VSS nfet_06v0 ad=13.936p pd=54.12u as=13.936p ps=54.12u w=53.6u l=0.7u
X337 VSS a_1852_148519# ESD_RAIL VSS nfet_06v0 ad=13.936p pd=54.12u as=13.936p ps=54.12u w=53.6u l=0.7u
X338 VSS a_1852_148519# ESD_RAIL VSS nfet_06v0 ad=13.936p pd=54.12u as=13.936p ps=54.12u w=53.6u l=0.7u
X339 a_3813_117064# a_1005_131545# ESD_RAIL ESD_RAIL pfet_06v0 ad=1.3p pd=5.52u as=2.2p ps=10.88u w=5u l=0.7u
X340 ESD_RAIL a_1852_148519# VSS VSS nfet_06v0 ad=13.936p pd=54.12u as=13.936p ps=54.12u w=53.6u l=0.7u
X341 ESD_RAIL a_1852_148519# VSS VSS nfet_06v0 ad=13.936p pd=54.12u as=23.584p ps=0.10808m w=53.6u l=0.7u
X342 ESD_RAIL a_2245_90628# VSS VSS nfet_06v0 ad=22p pd=0.10088m as=13p ps=50.52u w=50u l=0.7u
X343 ESD_RAIL a_1852_148519# VSS VSS nfet_06v0 ad=13.936p pd=54.12u as=13.936p ps=54.12u w=53.6u l=0.7u
X344 a_72676_90254# TERM_ENABLE TERM_VCM__P4 VSS nfet_06v0 ad=8.8p pd=40.88u as=8.8p ps=40.88u w=20u l=0.7u
X345 ESD_RAIL a_2245_90628# VSS VSS nfet_06v0 ad=13p pd=50.52u as=13p ps=50.52u w=50u l=0.7u
X346 ESD_RAIL a_2245_90628# VSS VSS nfet_06v0 ad=13p pd=50.52u as=13p ps=50.52u w=50u l=0.7u
X347 VSS a_1852_148519# ESD_RAIL VSS nfet_06v0 ad=13.936p pd=54.12u as=13.936p ps=54.12u w=53.6u l=0.7u
X348 VSS a_1852_148519# ESD_RAIL VSS nfet_06v0 ad=23.584p pd=0.10808m as=13.936p ps=54.12u w=53.6u l=0.7u
X349 a_91900_152846# TERM_TRIM3 TERM_VCM__N22 VSS nfet_06v0 ad=5.28p pd=24.88u as=5.28p ps=24.88u w=12u l=0.7u
X350 a_4789_117064# a_3813_117064# ESD_RAIL ESD_RAIL pfet_06v0 ad=1.3p pd=5.52u as=1.3p ps=5.52u w=5u l=0.7u
X351 ESD_RAIL a_1852_148519# VSS VSS nfet_06v0 ad=13.936p pd=54.12u as=13.936p ps=54.12u w=53.6u l=0.7u
X352 a_85492_152846_r# PAD_N__h16 VSS ppolyf_u r_width=2u r_length=1u
X353 a_69448_96914# TERM_ENABLE TERM_VCM__P1 VSS nfet_06v0 ad=8.8p pd=40.88u as=8.8p ps=40.88u w=20u l=0.7u
X354 VSS a_1852_148519# ESD_RAIL VSS nfet_06v0 ad=13.936p pd=54.12u as=13.936p ps=54.12u w=53.6u l=0.7u
X355 VSS a_1852_148519# ESD_RAIL VSS nfet_06v0 ad=13.936p pd=54.12u as=13.936p ps=54.12u w=53.6u l=0.7u
X356 PAD_P__h14 a_83356_91054_r# VSS ppolyf_u r_width=2u r_length=1u
X357 ESD_RAIL a_1852_148519# VSS VSS nfet_06v0 ad=13.936p pd=54.12u as=13.936p ps=54.12u w=53.6u l=0.7u
X358 ESD_RAIL a_1852_148519# VSS VSS nfet_06v0 ad=13.936p pd=54.12u as=13.936p ps=54.12u w=53.6u l=0.7u
X359 ESD_RAIL a_1852_148519# VSS VSS nfet_06v0 ad=13.936p pd=54.12u as=13.936p ps=54.12u w=53.6u l=0.7u
X360 ESD_RAIL a_1852_148519# VSS VSS nfet_06v0 ad=13.936p pd=54.12u as=13.936p ps=54.12u w=53.6u l=0.7u
X361 VSS a_2245_90628# ESD_RAIL VSS nfet_06v0 ad=13p pd=50.52u as=22p ps=0.10088m w=50u l=0.7u
X362 VSS a_2245_90628# ESD_RAIL VSS nfet_06v0 ad=13p pd=50.52u as=13p ps=50.52u w=50u l=0.7u
D21 PAD_P__dio ESD_RAIL diode_pd2nw_06v0 pj=51.8u area=22.5p
X363 ESD_RAIL a_1852_148519# VSS VSS nfet_06v0 ad=13.936p pd=54.12u as=13.936p ps=54.12u w=53.6u l=0.7u
X364 VSS a_1852_148519# ESD_RAIL VSS nfet_06v0 ad=13.936p pd=54.12u as=13.936p ps=54.12u w=53.6u l=0.7u
X365 VSS a_2245_90628# ESD_RAIL VSS nfet_06v0 ad=13p pd=50.52u as=13p ps=50.52u w=50u l=0.7u
X366 VSS a_2245_90628# ESD_RAIL VSS nfet_06v0 ad=13p pd=50.52u as=13p ps=50.52u w=50u l=0.7u
X367 PAD_P__h6 a_74812_90254_r# VSS ppolyf_u r_width=2u r_length=2.6u
X368 a_1852_148519# VSS VSS ppolyf_u_1k_6p0 r_width=1u r_length=6u
X369 ESD_RAIL a_1852_148519# VSS VSS nfet_06v0 ad=13.936p pd=54.12u as=13.936p ps=54.12u w=53.6u l=0.7u
X370 VSS a_1852_148519# ESD_RAIL VSS nfet_06v0 ad=13.936p pd=54.12u as=13.936p ps=54.12u w=53.6u l=0.7u
D22 PAD_P__dio ESD_RAIL diode_pd2nw_06v0 pj=51.8u area=22.5p
X371 VSS a_1852_148519# ESD_RAIL VSS nfet_06v0 ad=13.936p pd=54.12u as=13.936p ps=54.12u w=53.6u l=0.7u
X372 VSS a_1852_148519# ESD_RAIL VSS nfet_06v0 ad=23.584p pd=0.10808m as=13.936p ps=54.12u w=53.6u l=0.7u
X373 VDD w_71178_112088# w_71178_112088# w_71178_112088# pfet_06v0 ad=1.76p pd=8.88u as=1.76p ps=8.88u w=4u l=0.55u
X374 VSS a_2245_90628# ESD_RAIL VSS nfet_06v0 ad=13p pd=50.52u as=13p ps=50.52u w=50u l=0.7u
X375 a_90832_152846# TERM_TRIM3 TERM_VCM__N21 VSS nfet_06v0 ad=5.28p pd=24.88u as=5.28p ps=24.88u w=12u l=0.7u
X376 VSS a_1852_148519# ESD_RAIL VSS nfet_06v0 ad=13.936p pd=54.12u as=13.936p ps=54.12u w=53.6u l=0.7u
D23 VSS PAD_P__dio diode_nd2ps_06v0 pj=51.8u area=22.5p
X377 a_79084_152846_r# PAD_N__h10 VSS ppolyf_u r_width=2u r_length=1u
X378 ESD_RAIL a_1852_148519# VSS VSS nfet_06v0 ad=13.936p pd=54.12u as=23.584p ps=0.10808m w=53.6u l=0.7u
X379 VSS a_1852_148519# ESD_RAIL VSS nfet_06v0 ad=13.936p pd=54.12u as=13.936p ps=54.12u w=53.6u l=0.7u
X380 ESD_RAIL a_2245_90628# VSS VSS nfet_06v0 ad=13p pd=50.52u as=13p ps=50.52u w=50u l=0.7u
X381 ESD_RAIL a_2245_90628# VSS VSS nfet_06v0 ad=13p pd=50.52u as=13p ps=50.52u w=50u l=0.7u
X382 a_68216_149284_r# PAD_N__h0 VSS ppolyf_u r_width=2u r_length=2.6u
X383 ESD_RAIL a_1852_148519# VSS VSS nfet_06v0 ad=13.936p pd=54.12u as=13.936p ps=54.12u w=53.6u l=0.7u
X384 a_74812_90254# TERM_ENABLE TERM_VCM__P6 VSS nfet_06v0 ad=8.8p pd=40.88u as=8.8p ps=40.88u w=20u l=0.7u
X385 VSS a_3813_117064# a_4789_117064# VSS nfet_06v0 ad=1.3p pd=5.52u as=1.3p ps=5.52u w=5u l=0.7u
X386 ESD_RAIL a_1852_148519# VSS VSS nfet_06v0 ad=13.936p pd=54.12u as=13.936p ps=54.12u w=53.6u l=0.7u
X387 PAD_P__h12 a_81220_91054_r# VSS ppolyf_u r_width=2u r_length=1u
X388 a_69448_149284# TERM_ENABLE TERM_VCM__N1 VSS nfet_06v0 ad=8.8p pd=40.88u as=8.8p ps=40.88u w=20u l=0.7u
X389 VSS a_1852_148519# ESD_RAIL VSS nfet_06v0 ad=13.936p pd=54.12u as=13.936p ps=54.12u w=53.6u l=0.7u
X390 RX_N__dev VSS VSS VSS nfet_06v0 ad=1.76p pd=8.88u as=1.76p ps=8.88u w=4u l=0.7u
X391 VSS a_2245_90628# ESD_RAIL VSS nfet_06v0 ad=13p pd=50.52u as=13p ps=50.52u w=50u l=0.7u
X392 a_71608_152046_r# PAD_N__h3 VSS ppolyf_u r_width=2u r_length=2.6u
X393 ESD_RAIL a_1852_148519# VSS VSS nfet_06v0 ad=13.936p pd=54.12u as=23.584p ps=0.10808m w=53.6u l=0.7u
X394 ESD_RAIL a_1852_148519# VSS VSS nfet_06v0 ad=13.936p pd=54.12u as=13.936p ps=54.12u w=53.6u l=0.7u
X395 VSS a_4789_117064# a_2245_90628# VSS nfet_06v0 ad=1.3p pd=5.52u as=1.3p ps=5.52u w=5u l=0.7u
X396 PAD_P__h19 a_88696_91054_r# VSS ppolyf_u r_width=2u r_length=1u
X397 VSS a_1852_148519# ESD_RAIL VSS nfet_06v0 ad=13.936p pd=54.12u as=13.936p ps=54.12u w=53.6u l=0.7u
X398 VSS a_1852_148519# ESD_RAIL VSS nfet_06v0 ad=13.936p pd=54.12u as=13.936p ps=54.12u w=53.6u l=0.7u
X399 VSS a_4789_117064# a_2245_90628# VSS nfet_06v0 ad=1.3p pd=5.52u as=1.3p ps=5.52u w=5u l=0.7u
X400 VSS a_1852_148519# ESD_RAIL VSS nfet_06v0 ad=13.936p pd=54.12u as=13.936p ps=54.12u w=53.6u l=0.7u
X401 ESD_RAIL a_4789_117064# a_2245_90628# ESD_RAIL pfet_06v0 ad=1.3p pd=5.52u as=1.3p ps=5.52u w=5u l=0.7u
X402 a_94036_152846_r# PAD_N__h24 VSS ppolyf_u r_width=2u r_length=1u
X403 ESD_RAIL a_1852_148519# VSS VSS nfet_06v0 ad=13.936p pd=54.12u as=13.936p ps=54.12u w=53.6u l=0.7u
X404 VSS a_1852_148519# ESD_RAIL VSS nfet_06v0 ad=23.584p pd=0.10808m as=13.936p ps=54.12u w=53.6u l=0.7u
X405 a_1005_131545# a_13878_131545# ESD_RAIL ppolyf_u r_width=0.8u r_length=63.855u
X406 VSS a_2245_90628# ESD_RAIL VSS nfet_06v0 ad=13p pd=50.52u as=13p ps=50.52u w=50u l=0.7u
X407 VSS a_2245_90628# ESD_RAIL VSS nfet_06v0 ad=13p pd=50.52u as=13p ps=50.52u w=50u l=0.7u
X408 ESD_RAIL a_1852_148519# VSS VSS nfet_06v0 ad=13.936p pd=54.12u as=13.936p ps=54.12u w=53.6u l=0.7u
X409 VSS a_1852_148519# ESD_RAIL VSS nfet_06v0 ad=13.936p pd=54.12u as=13.936p ps=54.12u w=53.6u l=0.7u
X410 VSS a_1852_148519# ESD_RAIL VSS nfet_06v0 ad=13.936p pd=54.12u as=13.936p ps=54.12u w=53.6u l=0.7u
X411 ESD_RAIL a_1852_148519# VSS VSS nfet_06v0 ad=13.936p pd=54.12u as=23.584p ps=0.10808m w=53.6u l=0.7u
X412 ESD_RAIL a_1852_148519# VSS VSS nfet_06v0 ad=13.936p pd=54.12u as=23.584p ps=0.10808m w=53.6u l=0.7u
X413 ESD_RAIL a_2245_90628# VSS VSS nfet_06v0 ad=13p pd=50.52u as=13p ps=50.52u w=50u l=0.7u
X414 a_4789_117064# a_3813_117064# VSS VSS nfet_06v0 ad=1.3p pd=5.52u as=1.3p ps=5.52u w=5u l=0.7u
X415 ESD_RAIL a_1852_148519# VSS VSS nfet_06v0 ad=13.936p pd=54.12u as=13.936p ps=54.12u w=53.6u l=0.7u
X416 VSS a_1852_148519# ESD_RAIL VSS nfet_06v0 ad=13.936p pd=54.12u as=13.936p ps=54.12u w=53.6u l=0.7u
D24 PAD_P__dio ESD_RAIL diode_pd2nw_06v0 pj=51.8u area=22.5p
X417 VSS a_1852_148519# ESD_RAIL VSS nfet_06v0 ad=13.936p pd=54.12u as=13.936p ps=54.12u w=53.6u l=0.7u
X418 a_2245_90628# a_4789_117064# ESD_RAIL ESD_RAIL pfet_06v0 ad=1.3p pd=5.52u as=1.3p ps=5.52u w=5u l=0.7u
X419 a_68216_149284# TERM_ENABLE TERM_VCM__N0 VSS nfet_06v0 ad=8.8p pd=40.88u as=8.8p ps=40.88u w=20u l=0.7u
X420 VSS a_1852_148519# ESD_RAIL VSS nfet_06v0 ad=13.936p pd=54.12u as=13.936p ps=54.12u w=53.6u l=0.7u
X421 ESD_RAIL a_1852_148519# VSS VSS nfet_06v0 ad=13.936p pd=54.12u as=13.936p ps=54.12u w=53.6u l=0.7u
X422 ESD_RAIL a_1852_148519# VSS VSS nfet_06v0 ad=13.936p pd=54.12u as=13.936p ps=54.12u w=53.6u l=0.7u
X423 VSS a_1852_148519# ESD_RAIL VSS nfet_06v0 ad=13.936p pd=54.12u as=13.936p ps=54.12u w=53.6u l=0.7u
X424 a_88696_91054# TERM_TRIM3 TERM_VCM__P19 VSS nfet_06v0 ad=5.28p pd=24.88u as=5.28p ps=24.88u w=12u l=0.7u
X425 a_1005_132385# a_13878_132665# ESD_RAIL ppolyf_u r_width=0.8u r_length=63.855u
X426 ESD_RAIL a_2245_90628# VSS VSS nfet_06v0 ad=13p pd=50.52u as=13p ps=50.52u w=50u l=0.7u
X427 ESD_RAIL a_1852_148519# VSS VSS nfet_06v0 ad=13.936p pd=54.12u as=23.584p ps=0.10808m w=53.6u l=0.7u
X428 ESD_RAIL a_1852_148519# VSS VSS nfet_06v0 ad=13.936p pd=54.12u as=13.936p ps=54.12u w=53.6u l=0.7u
D25 VSS PAD_N__dio diode_nd2ps_06v0 pj=51.8u area=22.5p
X429 VSS a_1852_148519# ESD_RAIL VSS nfet_06v0 ad=23.584p pd=0.10808m as=13.936p ps=54.12u w=53.6u l=0.7u
X430 VSS a_2245_90628# ESD_RAIL VSS nfet_06v0 ad=13p pd=50.52u as=13p ps=50.52u w=50u l=0.7u
X431 a_87628_152846_r# PAD_N__h18 VSS ppolyf_u r_width=2u r_length=1u
X432 PAD_P__h10 a_79084_91054_r# VSS ppolyf_u r_width=2u r_length=1u
X433 a_86560_152846_r# PAD_N__h17 VSS ppolyf_u r_width=2u r_length=1u
X434 VSS a_2245_90628# ESD_RAIL VSS nfet_06v0 ad=13p pd=50.52u as=13p ps=50.52u w=50u l=0.7u
X435 a_76948_152046_r# PAD_N__h8 VSS ppolyf_u r_width=2u r_length=2.6u
X436 ESD_RAIL a_1852_148519# VSS VSS nfet_06v0 ad=13.936p pd=54.12u as=13.936p ps=54.12u w=53.6u l=0.7u
X437 VSS a_1852_148519# ESD_RAIL VSS nfet_06v0 ad=13.936p pd=54.12u as=13.936p ps=54.12u w=53.6u l=0.7u
X438 ESD_RAIL a_1852_148519# VSS VSS nfet_06v0 ad=13.936p pd=54.12u as=23.584p ps=0.10808m w=53.6u l=0.7u
X439 VSS a_1852_148519# ESD_RAIL VSS nfet_06v0 ad=13.936p pd=54.12u as=13.936p ps=54.12u w=53.6u l=0.7u
X440 ESD_RAIL a_4789_117064# a_2245_90628# ESD_RAIL pfet_06v0 ad=2.2p pd=10.88u as=1.3p ps=5.52u w=5u l=0.7u
X441 VSS a_1852_148519# ESD_RAIL VSS nfet_06v0 ad=13.936p pd=54.12u as=13.936p ps=54.12u w=53.6u l=0.7u
X442 ESD_RAIL a_1852_148519# VSS VSS nfet_06v0 ad=13.936p pd=54.12u as=13.936p ps=54.12u w=53.6u l=0.7u
X443 VSS a_1852_148519# ESD_RAIL VSS nfet_06v0 ad=13.936p pd=54.12u as=13.936p ps=54.12u w=53.6u l=0.7u
X444 VSS a_2245_90628# ESD_RAIL VSS nfet_06v0 ad=13p pd=50.52u as=13p ps=50.52u w=50u l=0.7u
X445 RX_N__dev VDD VDD VDD pfet_06v0 ad=1.76p pd=8.88u as=1.76p ps=8.88u w=4u l=0.55u
X446 a_1005_133505# a_13878_133785# ESD_RAIL ppolyf_u r_width=0.8u r_length=63.855u
X447 VSS a_2245_90628# ESD_RAIL VSS nfet_06v0 ad=13p pd=50.52u as=13p ps=50.52u w=50u l=0.7u
X448 a_73744_90254# TERM_ENABLE TERM_VCM__P5 VSS nfet_06v0 ad=8.8p pd=40.88u as=8.8p ps=40.88u w=20u l=0.7u
X449 a_75880_152046# TERM_ENABLE TERM_VCM__N7 VSS nfet_06v0 ad=8.8p pd=40.88u as=8.8p ps=40.88u w=20u l=0.7u
X450 ESD_RAIL a_1852_148519# VSS VSS nfet_06v0 ad=13.936p pd=54.12u as=13.936p ps=54.12u w=53.6u l=0.7u
X451 ESD_RAIL a_2245_90628# VSS VSS nfet_06v0 ad=13p pd=50.52u as=13p ps=50.52u w=50u l=0.7u
X452 ESD_RAIL a_1852_148519# VSS VSS nfet_06v0 ad=13.936p pd=54.12u as=13.936p ps=54.12u w=53.6u l=0.7u
X453 ESD_RAIL a_1852_148519# VSS VSS nfet_06v0 ad=13.936p pd=54.12u as=13.936p ps=54.12u w=53.6u l=0.7u
X454 ESD_RAIL a_1852_148519# VSS VSS nfet_06v0 ad=13.936p pd=54.12u as=13.936p ps=54.12u w=53.6u l=0.7u
X455 VSS a_1852_148519# ESD_RAIL VSS nfet_06v0 ad=13.936p pd=54.12u as=13.936p ps=54.12u w=53.6u l=0.7u
X456 a_73744_152046# TERM_ENABLE TERM_VCM__N5 VSS nfet_06v0 ad=8.8p pd=40.88u as=8.8p ps=40.88u w=20u l=0.7u
X457 ESD_RAIL a_2245_90628# VSS VSS nfet_06v0 ad=13p pd=50.52u as=13p ps=50.52u w=50u l=0.7u
X458 ESD_RAIL a_1852_148519# VSS VSS nfet_06v0 ad=13.936p pd=54.12u as=23.584p ps=0.10808m w=53.6u l=0.7u
X459 ESD_RAIL a_4789_117064# a_2245_90628# ESD_RAIL pfet_06v0 ad=1.3p pd=5.52u as=1.3p ps=5.52u w=5u l=0.7u
X460 a_94036_91054# TERM_TRIM3 TERM_VCM__P24 VSS nfet_06v0 ad=5.28p pd=24.88u as=5.28p ps=24.88u w=12u l=0.7u
X461 ESD_RAIL a_1852_148519# VSS VSS nfet_06v0 ad=13.936p pd=54.12u as=13.936p ps=54.12u w=53.6u l=0.7u
X462 a_2245_90628# VSS VSS ppolyf_u_1k_6p0 r_width=1u r_length=99.24u
X463 VSS a_1852_148519# ESD_RAIL VSS nfet_06v0 ad=13.936p pd=54.12u as=13.936p ps=54.12u w=53.6u l=0.7u
X464 VSS a_1852_148519# ESD_RAIL VSS nfet_06v0 ad=13.936p pd=54.12u as=13.936p ps=54.12u w=53.6u l=0.7u
X465 VSS a_1852_148519# ESD_RAIL VSS nfet_06v0 ad=13.936p pd=54.12u as=13.936p ps=54.12u w=53.6u l=0.7u
X466 VSS a_1852_148519# ESD_RAIL VSS nfet_06v0 ad=13.936p pd=54.12u as=13.936p ps=54.12u w=53.6u l=0.7u
D26 VSS PAD_N__dio diode_nd2ps_06v0 pj=51.8u area=22.5p
X467 a_4789_117064# a_3813_117064# VSS VSS nfet_06v0 ad=1.3p pd=5.52u as=1.3p ps=5.52u w=5u l=0.7u
X468 PAD_P__h5 a_73744_90254_r# VSS ppolyf_u r_width=2u r_length=2.6u
X469 RX_N__mim PAD_N__mim cap_mim_2f0_m4m5_noshield c_width=35u c_length=35u
D27 VSS ESD_RAIL diode_nd2ps_06v0 pj=82u area=40p
X470 VSS a_1852_148519# ESD_RAIL VSS nfet_06v0 ad=13.936p pd=54.12u as=13.936p ps=54.12u w=53.6u l=0.7u
X471 VSS a_1852_148519# ESD_RAIL VSS nfet_06v0 ad=13.936p pd=54.12u as=13.936p ps=54.12u w=53.6u l=0.7u
X472 VSS a_2245_90628# ESD_RAIL VSS nfet_06v0 ad=13p pd=50.52u as=13p ps=50.52u w=50u l=0.7u
X473 VSS a_1852_148519# ESD_RAIL VSS nfet_06v0 ad=13.936p pd=54.12u as=13.936p ps=54.12u w=53.6u l=0.7u
X474 ESD_RAIL a_1852_148519# VSS VSS nfet_06v0 ad=13.936p pd=54.12u as=13.936p ps=54.12u w=53.6u l=0.7u
X475 VSS a_2245_90628# ESD_RAIL VSS nfet_06v0 ad=13p pd=50.52u as=13p ps=50.52u w=50u l=0.7u
X476 VSS a_2245_90628# ESD_RAIL VSS nfet_06v0 ad=13p pd=50.52u as=13p ps=50.52u w=50u l=0.7u
X477 ESD_RAIL a_1852_148519# VSS VSS nfet_06v0 ad=13.936p pd=54.12u as=13.936p ps=54.12u w=53.6u l=0.7u
X478 VSS a_2245_90628# ESD_RAIL VSS nfet_06v0 ad=13p pd=50.52u as=13p ps=50.52u w=50u l=0.7u
X479 PAD_P__h7 a_75880_90254_r# VSS ppolyf_u r_width=2u r_length=2.6u
C0 TERM_VCM a_91900_91054# 3.28801f
C1 TERM_VCM a_94036_152846# 2.32568f
C2 ESD_RAIL m3_31296_125300# 0.4985f
C3 TERM_VCM a_72676_152046# 2.42132f
C4 a_1005_131825# ESD_RAIL 0.53823f
C5 a_80152_152846# TERM_TRIM1 0.28932f
C6 a_1005_131545# a_1005_132945# 0
C7 PAD_N a_73744_152046# 0.04756f
C8 a_82288_152846# a_79084_152846# 0
C9 TERM_VCM a_70540_152046# 2.26906f
C10 TERM_VCM a_88696_91054# 2.2489f
C11 w_71178_112088# TERM_TRIM0 0.17102f
C12 TERM_TRIM3 w_71178_112088# 0.24351f
C13 a_1005_132385# ESD_RAIL 0.53823f
C14 TERM_VCM a_70540_90254# 2.26906f
C15 m4_29696_133300# m3_29696_133300# 0.15111f
C16 PAD_N m3_31296_117300# 0.03396f
C17 m4_32896_117300# m3_32896_117300# 0.15111f
C18 m4_31296_117300# m3_31296_117300# 0.15111f
C19 a_92968_91054# PAD_P 0.10003f
C20 TERM_ENABLE a_73744_90254# 0.42524f
C21 PAD_N VBIAS 0.15966f
C22 a_86560_152846# a_88696_152846# 0.2726f
C23 a_86560_152846# a_83356_152846# 0.01123f
C24 PAD_N a_79084_152846# 0.10321f
C25 a_92968_152846# TERM_TRIM3 0.28932f
C26 a_1005_132385# a_1005_132945# 0.0346f
C27 TERM_ENABLE a_71608_90254# 0.4243f
C28 TERM_ENABLE a_71608_152046# 0.4243f
C29 a_82288_91054# a_81220_91054# 0.10531f
C30 a_69448_149284# a_70540_152046# 0.13311f
C31 a_86560_152846# a_84424_152846# 0.17288f
C32 a_94036_91054# TERM_TRIM3 0.27606f
C33 a_81220_152846# a_78016_152046# 0
C34 a_75880_90254# TERM_ENABLE 0.4244f
C35 TERM_ENABLE a_78016_152046# 0.41103f
C36 TERM_VCM a_89764_152846# 2.00734f
C37 a_83356_91054# PAD_P 0.10313f
C38 a_82288_152846# a_83356_152846# 0.64368f
C39 a_91900_152846# a_88696_152846# 0.0331f
C40 a_84424_152846# a_82288_152846# 0.08318f
C41 a_90832_91054# a_89764_91054# 0.19968f
C42 PAD_N PAD_P 36.4223f
C43 TERM_VCM a_85492_152846# 2.14296f
C44 TERM_ENABLE a_68216_149284# 0.4243f
C45 a_80152_152846# a_78016_152046# 0.01596f
C46 PAD_N a_88696_152846# 0.10313f
C47 TERM_TRIM2 a_81220_91054# 0.01326f
C48 a_90832_152846# TERM_TRIM3 0.28932f
C49 PAD_N a_83356_152846# 0.10313f
C50 a_90832_152846# a_87628_152846# 0.31618f
C51 m3_34460_89900# PAD_P 0.04061f
C52 PAD_N a_84424_152846# 0.10313f
C53 a_92968_91054# a_91900_91054# 1.09827f
C54 TERM_VCM a_75880_152046# 2.29198f
C55 m4_34496_125300# PAD_P 0.01598f
C56 a_74812_90254# TERM_ENABLE 0.42606f
C57 PAD_N m4_29696_117300# 0.01425f
C58 m2_2279_124800# a_1005_134065# 0
C59 a_75880_90254# a_73744_90254# 0
C60 m4_29696_133300# PAD_N 0.01425f
C61 w_71178_112088# ESD_RAIL 0.08713f
C62 TERM_TRIM2 TERM_TRIM0 0.07657f
C63 TERM_TRIM2 TERM_TRIM3 49.1703f
C64 m3_34460_105900# PAD_N 0.04492f
C65 a_92968_91054# a_88696_91054# 0.00866f
C66 PAD_N m3_32896_117300# 0.03396f
C67 m3_29660_89900# PAD_P 0.03097f
C68 a_82288_91054# a_85492_91054# 0.00939f
C69 TERM_TRIM1 a_81220_91054# 0.27606f
C70 m3_32860_89900# ESD_RAIL 0
C71 PAD_P VBIAS 0.15544f
C72 m3_34496_133300# ESD_RAIL 0.4985f
C73 RX_P w_71178_112088# 2.17742f
C74 VDD w_71178_112088# 5.53293f
C75 a_78016_90254# PAD_P 0.04756f
C76 m3_29696_101300# ESD_RAIL 0.44823f
C77 a_91900_152846# a_94036_152846# 0.13174f
C78 TERM_VCM w_71178_112088# 0.37908f
C79 m4_31296_101300# ESD_RAIL 0.5351f
C80 TERM_ENABLE TERM_TRIM0 30.6415f
C81 TERM_ENABLE TERM_TRIM3 0.08127f
C82 ESD_RAIL m4_34496_133300# 0.5351f
C83 PAD_N a_94036_152846# 0.09836f
C84 a_72676_90254# TERM_ENABLE 0.4243f
C85 m3_29696_125300# m4_29696_125300# 0.15111f
C86 a_90832_91054# a_86560_91054# 0
C87 PAD_N a_72676_152046# 0.04756f
C88 a_74812_90254# a_73744_90254# 0.24052f
C89 TERM_VCM a_92968_152846# 2.42969f
C90 TERM_TRIM1 TERM_TRIM0 44.3258f
C91 TERM_TRIM3 TERM_TRIM1 0.08733f
C92 a_86560_152846# a_89764_152846# 0.02726f
C93 PAD_N a_70540_152046# 0.04756f
C94 m3_32896_101300# ESD_RAIL 0.4985f
C95 RX_N w_71178_112088# 2.17714f
C96 a_94036_91054# TERM_VCM 2.32568f
C97 a_86560_152846# a_85492_152846# 0.77991f
C98 TERM_TRIM2 a_85492_91054# 0.27606f
C99 a_87628_91054# PAD_P 0.10313f
C100 a_84424_91054# a_86560_91054# 0.17288f
C101 a_75880_90254# a_74812_90254# 0.15815f
C102 a_90832_91054# TERM_TRIM3 0.28932f
C103 TERM_VCM a_76948_152046# 2.67432f
C104 m4_29696_101300# m3_29696_101300# 0.15111f
C105 a_89764_91054# a_86560_91054# 0.02726f
C106 TERM_VCM a_82288_91054# 2.40617f
C107 m3_31296_133300# ESD_RAIL 0.4985f
C108 a_72676_152046# a_73744_152046# 0.14941f
C109 a_84424_152846# a_83356_152846# 0.26519f
C110 a_91900_152846# a_89764_152846# 0.16933f
C111 a_82288_152846# a_85492_152846# 0.00939f
C112 a_84424_91054# TERM_TRIM3 0
C113 a_72676_90254# a_73744_90254# 0.14941f
C114 m3_31260_89900# PAD_P 0.04061f
C115 TERM_VCM a_90832_152846# 2.01476f
C116 TERM_VCM a_74812_152046# 2.2233f
C117 a_13878_131545# a_13878_132105# 0.0346f
C118 a_82288_91054# a_79084_91054# 0
C119 PAD_N a_89764_152846# 0.10313f
C120 a_13878_134345# ESD_RAIL 0.5677f
C121 m4_31296_101300# m3_31296_101300# 0.15111f
C122 a_89764_91054# TERM_TRIM3 0.28932f
C123 a_72676_90254# a_71608_90254# 0.14045f
C124 a_68216_96914# PAD_P 0.12057f
C125 m3_32860_105900# PAD_N 0.04492f
C126 ESD_RAIL m3_32896_133300# 0.4985f
C127 a_3813_117064# a_2245_90628# 0.00994f
C128 a_82288_91054# a_80152_91054# 0.03597f
C129 PAD_N a_85492_152846# 0.10313f
C130 m4_31296_125300# ESD_RAIL 0.5351f
C131 RX_P TERM_TRIM2 0.14387f
C132 VDD TERM_TRIM2 0.28557f
C133 TERM_TRIM0 a_78016_152046# 0.00894f
C134 a_3813_117064# a_1005_131545# 2.44008f
C135 a_13878_132105# a_13878_132665# 0.0346f
C136 TERM_VCM TERM_TRIM2 5.12464f
C137 a_69448_96914# PAD_P 0.04756f
C138 a_87628_91054# a_91900_91054# 0.00449f
C139 a_13878_133785# a_13878_134345# 0.0346f
C140 PAD_N a_75880_152046# 0.04756f
C141 PAD_P a_91900_91054# 0.10003f
C142 m3_29696_117300# ESD_RAIL 0.44823f
C143 m4_32896_133300# ESD_RAIL 0.5351f
C144 m3_32896_125300# m4_32896_125300# 0.15111f
C145 RX_P TERM_ENABLE 0
C146 VDD TERM_ENABLE 12.9618f
C147 a_87628_91054# a_88696_91054# 0.85754f
C148 TERM_VCM a_81220_152846# 1.99423f
C149 m4_31296_133300# m3_31296_133300# 0.15111f
C150 a_1005_134065# ESD_RAIL 0.57348f
C151 a_84424_91054# a_85492_91054# 0.72556f
C152 a_94036_91054# a_92968_91054# 1.15263f
C153 PAD_P a_88696_91054# 0.10313f
C154 TERM_VCM TERM_ENABLE 25.0657f
C155 a_70540_90254# PAD_P 0.04756f
C156 RX_P TERM_TRIM1 0.14387f
C157 VDD TERM_TRIM1 0.28454f
C158 a_89764_91054# a_85492_91054# 0.00355f
C159 ESD_RAIL m4_32896_101300# 0.5351f
C160 a_74812_90254# a_72676_90254# 0
C161 TERM_VCM TERM_TRIM1 3.78482f
C162 m3_31296_125300# PAD_P 0.03396f
C163 m3_32896_125300# ESD_RAIL 0.4985f
C164 a_75880_152046# a_73744_152046# 0
C165 a_68216_96914# a_69448_96914# 0.13125f
C166 TERM_ENABLE a_79084_91054# 0.00349f
C167 PAD_N w_71178_112088# 7.24362f
C168 TERM_ENABLE a_76948_90254# 0.42442f
C169 TERM_ENABLE a_69448_149284# 0.4243f
C170 TERM_TRIM3 a_86560_91054# 0.28932f
C171 RX_N TERM_ENABLE 0.14434f
C172 a_80152_152846# TERM_VCM 2.24523f
C173 a_91900_152846# a_92968_152846# 1.09827f
C174 TERM_TRIM1 a_79084_91054# 0.01327f
C175 TERM_VCM a_90832_91054# 2.01476f
C176 a_86560_152846# a_90832_152846# 0
C177 a_92968_152846# PAD_N 0.10003f
C178 m4_34496_101300# m3_34496_101300# 0.15111f
C179 m4_34496_101300# ESD_RAIL 0.5351f
C180 m3_34496_133300# PAD_N 0.03396f
C181 TERM_TRIM1 a_80152_91054# 0.28932f
C182 m4_29696_125300# ESD_RAIL 0.48045f
C183 a_88696_152846# a_89764_152846# 0.94068f
C184 TERM_TRIM3 TERM_TRIM0 0.07988f
C185 a_87628_152846# TERM_TRIM3 0.28935f
C186 TERM_VCM a_73744_90254# 2.49447f
C187 a_82288_91054# a_83356_91054# 0.64368f
C188 PAD_N m4_34496_133300# 0.02435f
C189 TERM_VCM a_84424_91054# 3.02567f
C190 PAD_N a_76948_152046# 0.04756f
C191 a_88696_152846# a_85492_152846# 0.01848f
C192 a_85492_152846# a_83356_152846# 0.1405f
C193 a_69448_96914# a_70540_90254# 0.13311f
C194 TERM_VCM a_71608_90254# 2.35823f
C195 m3_29696_125300# ESD_RAIL 0.44823f
C196 TERM_VCM a_71608_152046# 2.35823f
C197 a_91900_91054# a_88696_91054# 0.0331f
C198 a_4789_117064# ESD_RAIL 16.8853f
C199 TERM_VCM a_89764_91054# 2.00734f
C200 m2_2279_124800# ESD_RAIL 5.47988f
C201 a_84424_152846# a_85492_152846# 0.72556f
C202 w_71178_112088# VBIAS 1.98187f
C203 TERM_VCM a_75880_90254# 2.29198f
C204 a_91900_152846# a_90832_152846# 0.09974f
C205 a_1005_133505# a_1005_134065# 0.0346f
C206 a_13878_131545# ESD_RAIL 0.56772f
C207 TERM_VCM a_78016_152046# 2.25881f
C208 a_85492_91054# a_86560_91054# 0.77991f
C209 a_90832_152846# PAD_N 0.1091f
C210 m2_2279_124800# a_1005_132945# 0
C211 PAD_N a_74812_152046# 0.04756f
C212 a_13878_132105# ESD_RAIL 0.53942f
C213 TERM_TRIM2 a_82288_152846# 0.28932f
C214 a_2245_90628# a_1005_131545# 0.01301f
C215 ESD_RAIL m3_34496_125300# 0.4985f
C216 a_83356_91054# TERM_TRIM2 0.28932f
C217 PAD_N m3_31296_133300# 0.03396f
C218 a_75880_90254# a_76948_90254# 0.24993f
C219 a_13878_132665# ESD_RAIL 0.53916f
C220 TERM_VCM a_68216_149284# 2.07251f
C221 PAD_N TERM_TRIM2 0.25684f
C222 TERM_TRIM3 a_85492_91054# 0.01326f
C223 a_89764_152846# a_94036_152846# 0.0102f
C224 w_71178_112088# PAD_P 0.75903f
C225 a_79084_152846# a_76948_152046# 0.01248f
C226 a_1005_131545# a_1005_131825# 0.03725f
C227 a_82288_152846# a_81220_152846# 0.10531f
C228 a_73744_152046# a_74812_152046# 0.24052f
C229 TERM_VCM a_74812_90254# 2.2233f
C230 PAD_N m3_32896_133300# 0.03396f
C231 a_90832_91054# a_92968_91054# 0
C232 a_1005_131545# a_1005_132385# 0
C233 a_69448_149284# a_68216_149284# 0.13125f
C234 m3_32860_89900# PAD_P 0.04061f
C235 PAD_N a_81220_152846# 0.10746f
C236 a_92968_152846# a_88696_152846# 0.00866f
C237 a_1005_131825# a_1005_132385# 0.0346f
C238 PAD_N TERM_ENABLE 0.33094f
C239 TERM_VCM a_86560_91054# 2.01082f
C240 TERM_VCM a_81220_91054# 1.99423f
C241 m3_29696_101300# PAD_P 0.02453f
C242 a_94036_91054# PAD_P 0.09836f
C243 m4_31296_101300# PAD_P 0.01598f
C244 a_80152_152846# a_82288_152846# 0.03597f
C245 m2_2279_124800# a_1005_133505# 0
C246 PAD_N m3_29696_117300# 0.02453f
C247 PAD_N TERM_TRIM1 0.25684f
C248 a_92968_91054# a_89764_91054# 0.12994f
C249 RX_P TERM_TRIM0 0.16216f
C250 RX_P TERM_TRIM3 0.14387f
C251 TERM_TRIM2 VBIAS 0.17974f
C252 VDD TERM_TRIM0 0.28403f
C253 a_82288_91054# PAD_P 0.10313f
C254 a_81220_91054# a_79084_91054# 0.13387f
C255 VDD TERM_TRIM3 4.05215f
C256 PAD_N m4_32896_133300# 0.01598f
C257 a_80152_152846# PAD_N 0.10321f
C258 TERM_VCM TERM_TRIM0 4.39961f
C259 TERM_VCM TERM_TRIM3 7.81019f
C260 TERM_VCM a_87628_152846# 3.22474f
C261 m3_32896_101300# PAD_P 0.03396f
C262 TERM_VCM a_72676_90254# 2.42132f
C263 a_81220_91054# a_80152_91054# 0.25062f
C264 TERM_ENABLE a_73744_152046# 0.42524f
C265 a_89764_152846# a_85492_152846# 0.00355f
C266 a_90832_152846# a_88696_152846# 0.13655f
C267 a_84424_91054# a_83356_91054# 0.26519f
C268 a_79084_91054# TERM_TRIM0 0.27606f
C269 TERM_ENABLE VBIAS 0.34917f
C270 ESD_RAIL m4_34496_117300# 0.5351f
C271 a_81220_152846# a_79084_152846# 0.13387f
C272 TERM_ENABLE a_78016_90254# 0.41103f
C273 TERM_ENABLE a_79084_152846# 0.00349f
C274 a_92968_152846# a_94036_152846# 1.15263f
C275 m4_32896_125300# ESD_RAIL 0.5351f
C276 TERM_TRIM2 PAD_P 0.07529f
C277 TERM_TRIM1 VBIAS 0.17732f
C278 PAD_N a_71608_152046# 0.04756f
C279 a_94036_91054# a_91900_91054# 0.13174f
C280 TERM_TRIM1 a_79084_152846# 0.01327f
C281 TERM_TRIM2 a_83356_152846# 0.28932f
C282 PAD_N a_78016_152046# 0.04756f
C283 ESD_RAIL m3_34496_101300# 0.4985f
C284 TERM_TRIM2 a_84424_152846# 0.28933f
C285 a_80152_152846# a_79084_152846# 0.46856f
C286 TERM_VCM a_85492_91054# 2.14296f
C287 m4_31296_125300# PAD_P 0.01598f
C288 TERM_ENABLE PAD_P 0.09923f
C289 a_1005_132945# ESD_RAIL 0.53823f
C290 a_81220_152846# a_83356_152846# 0
C291 PAD_N a_68216_149284# 0.12057f
C292 a_90832_152846# a_94036_152846# 0.00419f
C293 TERM_TRIM1 PAD_P 0.07651f
C294 a_13878_133785# ESD_RAIL 0.53942f
C295 a_72676_152046# a_74812_152046# 0
C296 a_86560_152846# TERM_TRIM3 0.28932f
C297 a_92968_91054# TERM_TRIM3 0.28932f
C298 a_86560_152846# a_87628_152846# 0.18097f
C299 a_92968_152846# a_89764_152846# 0.12994f
C300 a_90832_91054# a_87628_91054# 0.31618f
C301 m4_29696_101300# ESD_RAIL 0.48045f
C302 ESD_RAIL a_1852_148519# 0.3438p
C303 a_83356_91054# a_81220_91054# 0
C304 a_83356_91054# a_86560_91054# 0.01123f
C305 VDD RX_P 2.31443f
C306 m3_29696_117300# m4_29696_117300# 0.15111f
C307 a_90832_91054# PAD_P 0.1091f
C308 a_80152_152846# a_83356_152846# 0.00715f
C309 a_75880_90254# a_78016_90254# 0.01025f
C310 a_68216_96914# TERM_ENABLE 0.4243f
C311 PAD_P m4_32896_101300# 0.01598f
C312 a_79084_152846# a_78016_152046# 0.27297f
C313 TERM_VCM RX_P 6.30872f
C314 TERM_VCM VDD 3.62756f
C315 m3_32896_125300# PAD_P 0.03396f
C316 m4_34496_125300# m3_34496_125300# 0.15111f
C317 a_73744_90254# PAD_P 0.04756f
C318 a_3813_117064# a_4789_117064# 3.03168f
C319 m3_31296_101300# ESD_RAIL 0.4985f
C320 a_84424_91054# a_87628_91054# 0.01397f
C321 a_84424_91054# PAD_P 0.10313f
C322 m4_31296_133300# ESD_RAIL 0.5351f
C323 TERM_ENABLE a_69448_96914# 0.4243f
C324 a_71608_90254# PAD_P 0.04756f
C325 a_89764_91054# a_87628_91054# 0.12483f
C326 m4_32896_117300# ESD_RAIL 0.5351f
C327 a_91900_152846# TERM_TRIM3 0.2894f
C328 a_1005_133505# ESD_RAIL 0.53842f
C329 RX_P RX_N 3.37337f
C330 a_91900_152846# a_87628_152846# 0.00449f
C331 VDD RX_N 8.13768f
C332 a_89764_91054# PAD_P 0.10313f
C333 TERM_VCM a_79084_91054# 2.71834f
C334 TERM_VCM a_76948_90254# 2.67432f
C335 TERM_VCM a_69448_149284# 2.21943f
C336 m4_34496_101300# PAD_P 0.01598f
C337 PAD_N TERM_TRIM0 0.25684f
C338 PAD_N TERM_TRIM3 0.40303f
C339 a_90832_152846# a_89764_152846# 0.19968f
C340 TERM_VCM RX_N 6.84313f
C341 a_87628_152846# PAD_N 0.10313f
C342 TERM_ENABLE a_72676_152046# 0.4243f
C343 m3_29696_133300# ESD_RAIL 0.44823f
C344 m4_29696_125300# PAD_P 0.01425f
C345 a_75880_90254# PAD_P 0.04756f
C346 TERM_VCM a_80152_91054# 2.24523f
C347 a_75880_152046# a_76948_152046# 0.24993f
C348 a_1005_132945# a_1005_133505# 0.0346f
C349 TERM_ENABLE a_70540_152046# 0.4243f
C350 m3_29660_105900# ESD_RAIL -0
C351 m3_34496_117300# m4_34496_117300# 0.15111f
C352 TERM_ENABLE a_70540_90254# 0.4243f
C353 a_79084_91054# a_76948_90254# 0.01248f
C354 m4_31296_125300# m3_31296_125300# 0.15111f
C355 m3_29696_125300# PAD_P 0.02453f
C356 a_80152_91054# a_79084_91054# 0.46856f
C357 a_90832_91054# a_91900_91054# 0.09974f
C358 a_78016_90254# a_81220_91054# 0
C359 a_75880_152046# a_74812_152046# 0.15815f
C360 TERM_TRIM2 a_85492_152846# 0.27606f
C361 a_13878_133225# a_13878_132665# 0.0346f
C362 m3_34496_117300# ESD_RAIL 0.4985f
C363 a_83356_91054# a_85492_91054# 0.1405f
C364 a_90832_91054# a_88696_91054# 0.13655f
C365 a_74812_90254# PAD_P 0.04756f
C366 VBIAS TERM_TRIM0 0.17628f
C367 TERM_TRIM3 VBIAS 4.00884f
C368 PAD_P m3_34496_125300# 0.03396f
C369 PAD_N m4_34496_117300# 0.02435f
C370 a_79084_152846# TERM_TRIM0 0.27606f
C371 a_78016_90254# TERM_TRIM0 0.00894f
C372 a_89764_91054# a_91900_91054# 0.16933f
C373 a_87628_91054# a_86560_91054# 0.18097f
C374 a_72676_152046# a_71608_152046# 0.14045f
C375 TERM_VCM a_86560_152846# 2.01082f
C376 m3_34496_133300# m4_34496_133300# 0.15111f
C377 TERM_VCM a_92968_91054# 2.42969f
C378 a_81220_91054# PAD_P 0.10746f
C379 PAD_P a_86560_91054# 0.10313f
C380 a_70540_152046# a_71608_152046# 0.13588f
C381 a_71608_90254# a_70540_90254# 0.13588f
C382 a_89764_91054# a_88696_91054# 0.94068f
C383 PAD_N ESD_RAIL 50.7909f
C384 m4_31296_117300# ESD_RAIL 0.5351f
C385 TERM_ENABLE a_75880_152046# 0.4244f
C386 a_92968_152846# a_90832_152846# 0
C387 TERM_TRIM3 a_87628_91054# 0.28935f
C388 PAD_P TERM_TRIM0 0.08989f
C389 TERM_TRIM3 PAD_P 0.13496f
C390 ESD_RAIL m3_34460_89900# 0
C391 TERM_VCM a_82288_152846# 2.40617f
C392 a_72676_90254# PAD_P 0.04756f
C393 TERM_TRIM2 w_71178_112088# 0.14534f
C394 TERM_TRIM3 a_88696_152846# 0.28932f
C395 a_87628_152846# a_88696_152846# 0.85754f
C396 TERM_VCM a_83356_91054# 2.01072f
C397 m4_34496_125300# ESD_RAIL 0.5351f
C398 VDD PAD_N 0.39442f
C399 TERM_VCM a_91900_152846# 3.28801f
C400 a_4789_117064# a_2245_90628# 11.6307f
C401 TERM_TRIM3 a_84424_152846# 0
C402 a_87628_152846# a_84424_152846# 0.01397f
C403 TERM_VCM PAD_N 4.46952f
C404 a_4789_117064# a_1005_131545# 0.02926f
C405 m2_2279_124800# a_1005_131545# 0.05457f
C406 m3_31296_117300# ESD_RAIL 0.4985f
C407 TERM_ENABLE w_71178_112088# 16.5641f
C408 PAD_N a_1852_148519# 0.106f
C409 m3_29660_89900# ESD_RAIL 0
C410 a_83356_91054# a_80152_91054# 0.00715f
C411 m2_2279_124800# a_1005_131825# 0
C412 a_3813_117064# ESD_RAIL 5.25092f
C413 PAD_N a_69448_149284# 0.04756f
C414 PAD_N RX_N 16.0706f
C415 TERM_TRIM1 w_71178_112088# 0.1509f
C416 a_82288_91054# TERM_TRIM2 0.28932f
C417 m2_2279_124800# a_1005_132385# 0
C418 a_85492_91054# a_87628_91054# 0.21991f
C419 TERM_VCM a_73744_152046# 2.49447f
C420 a_85492_91054# PAD_P 0.10313f
C421 a_88696_91054# a_86560_91054# 0.2726f
C422 m4_31296_133300# PAD_N 0.01598f
C423 m4_32896_125300# PAD_P 0.01598f
C424 RX_P VBIAS 0.079f
C425 TERM_TRIM3 a_91900_91054# 0.2894f
C426 VDD VBIAS 6.80037f
C427 PAD_N m4_32896_117300# 0.01598f
C428 a_13878_133225# ESD_RAIL 0.53916f
C429 TERM_TRIM3 a_94036_152846# 0.27606f
C430 a_75880_152046# a_78016_152046# 0.01025f
C431 TERM_VCM VBIAS 15.9004f
C432 TERM_ENABLE a_76948_152046# 0.42442f
C433 TERM_VCM a_78016_90254# 2.25881f
C434 TERM_VCM a_79084_152846# 2.71834f
C435 PAD_N m3_29696_133300# 0.02453f
C436 PAD_P m3_34496_101300# 0.03396f
C437 ESD_RAIL PAD_P 56.6713f
C438 TERM_TRIM3 a_88696_91054# 0.28932f
C439 PAD_N m3_29660_105900# 0.03097f
C440 a_94036_91054# a_90832_91054# 0.00419f
C441 RX_N VBIAS 0.24116f
C442 a_78016_90254# a_79084_91054# 0.27297f
C443 a_13878_133785# a_13878_133225# 0.0346f
C444 TERM_ENABLE a_74812_152046# 0.42606f
C445 a_78016_90254# a_76948_90254# 0.43572f
C446 ESD_RAIL m4_29696_117300# 0.48045f
C447 a_78016_90254# a_80152_91054# 0.01596f
C448 RX_P PAD_P 16.0706f
C449 VDD PAD_P 0.39442f
C450 a_86560_152846# PAD_N 0.10313f
C451 TERM_VCM a_87628_91054# 3.22474f
C452 m3_31260_89900# ESD_RAIL 0
C453 TERM_VCM PAD_P 4.08609f
C454 m4_29696_133300# ESD_RAIL 0.48045f
C455 TERM_TRIM2 a_81220_152846# 0.01326f
C456 m3_34496_117300# PAD_N 0.03396f
C457 TERM_VCM a_88696_152846# 2.2489f
C458 TERM_TRIM2 TERM_ENABLE 0.07746f
C459 TERM_VCM a_83356_152846# 2.01072f
C460 TERM_TRIM3 a_89764_152846# 0.28932f
C461 a_94036_91054# a_89764_91054# 0.0102f
C462 ESD_RAIL m3_32896_117300# 0.4985f
C463 a_87628_152846# a_89764_152846# 0.12483f
C464 m3_32896_101300# m4_32896_101300# 0.15111f
C465 m4_29696_101300# PAD_P 0.01425f
C466 PAD_P a_1852_148519# 0.25621f
C467 TERM_VCM a_84424_152846# 3.02567f
C468 TERM_TRIM2 TERM_TRIM1 46.0549f
C469 a_79084_91054# PAD_P 0.10321f
C470 a_82288_91054# a_84424_91054# 0.08318f
C471 PAD_P a_76948_90254# 0.04756f
C472 TERM_TRIM3 a_85492_152846# 0.01326f
C473 a_87628_152846# a_85492_152846# 0.21991f
C474 PAD_N a_82288_152846# 0.10313f
C475 a_85492_91054# a_88696_91054# 0.01848f
C476 a_80152_91054# PAD_P 0.10321f
C477 m3_31296_101300# PAD_P 0.03396f
C478 a_78016_152046# a_76948_152046# 0.43572f
C479 a_91900_152846# PAD_N 0.10003f
C480 TERM_VCM a_68216_96914# 2.07251f
C481 m4_32896_133300# m3_32896_133300# 0.15111f
C482 m4_31296_117300# PAD_N 0.01598f
C483 a_81220_152846# TERM_TRIM1 0.27606f
C484 TERM_ENABLE TERM_TRIM1 0.09198f
C485 a_2245_90628# ESD_RAIL 0.24349p
C486 PAD_N m3_31260_105900# 0.04492f
C487 a_80152_152846# a_81220_152846# 0.25062f
C488 a_84424_91054# TERM_TRIM2 0.28933f
C489 TERM_VCM a_69448_96914# 2.21943f
C490 a_1005_131545# ESD_RAIL 97.1325f
C491 RX_P VSS 43.3929f
C492 VBIAS VSS 8.6617f
C493 RX_N VSS 37.5203f
C494 PAD_P VSS 0.42273p
C495 PAD_N VSS 0.40526p
C496 TERM_TRIM3 VSS 62.7203f
C497 TERM_TRIM2 VSS 20.8792f
C498 TERM_TRIM1 VSS 13.0932f
C499 TERM_TRIM0 VSS 13.0174f
C500 TERM_VCM VSS 0.2863p
C501 TERM_ENABLE VSS 40.1365f
C502 VDD VSS 31.8661f
C503 ESD_RAIL VSS 3263.27133f
C504 m4_34496_101300# VSS 0.06434f $ **FLOATING
C505 m4_32896_101300# VSS 0.06434f $ **FLOATING
C506 m4_31296_101300# VSS 0.06434f $ **FLOATING
C507 m4_29696_101300# VSS 0.12191f $ **FLOATING
C508 m4_34496_117300# VSS 0.05645f $ **FLOATING
C509 m4_32896_117300# VSS 0.06434f $ **FLOATING
C510 m4_31296_117300# VSS 0.06434f $ **FLOATING
C511 m4_29696_117300# VSS 0.12191f $ **FLOATING
C512 m4_34496_125300# VSS 0.06434f $ **FLOATING
C513 m4_32896_125300# VSS 0.06434f $ **FLOATING
C514 m4_31296_125300# VSS 0.06434f $ **FLOATING
C515 m4_29696_125300# VSS 0.12191f $ **FLOATING
C516 m4_34496_133300# VSS 0.05645f $ **FLOATING
C517 m4_32896_133300# VSS 0.06434f $ **FLOATING
C518 m4_31296_133300# VSS 0.06434f $ **FLOATING
C519 m4_29696_133300# VSS 0.12191f $ **FLOATING
C520 m3_34460_89900# VSS 1.1519f $ **FLOATING
C521 m3_32860_89900# VSS 1.1519f $ **FLOATING
C522 m3_31260_89900# VSS 1.1519f $ **FLOATING
C523 m3_29660_89900# VSS 1.16765f $ **FLOATING
C524 m3_34496_101300# VSS 0.07041f $ **FLOATING
C525 m3_32896_101300# VSS 0.07041f $ **FLOATING
C526 m3_31296_101300# VSS 0.07041f $ **FLOATING
C527 m3_29696_101300# VSS 0.13352f $ **FLOATING
C528 m3_34460_105900# VSS 1.14905f $ **FLOATING
C529 m3_32860_105900# VSS 1.14905f $ **FLOATING
C530 m3_31260_105900# VSS 1.14905f $ **FLOATING
C531 m3_29660_105900# VSS 1.16802f $ **FLOATING
C532 m3_34496_117300# VSS 0.07041f $ **FLOATING
C533 m3_32896_117300# VSS 0.07041f $ **FLOATING
C534 m3_31296_117300# VSS 0.07041f $ **FLOATING
C535 m3_29696_117300# VSS 0.13352f $ **FLOATING
C536 m3_34496_125300# VSS 0.07041f $ **FLOATING
C537 m3_32896_125300# VSS 0.07041f $ **FLOATING
C538 m3_31296_125300# VSS 0.07041f $ **FLOATING
C539 m3_29696_125300# VSS 0.13352f $ **FLOATING
C540 m3_34496_133300# VSS 0.07041f $ **FLOATING
C541 m3_32896_133300# VSS 0.07041f $ **FLOATING
C542 m3_31296_133300# VSS 0.07041f $ **FLOATING
C543 m3_29696_133300# VSS 0.13352f $ **FLOATING
C544 m2_2279_124800# VSS 7.46506f $ **FLOATING
C545 a_94036_91054# VSS 5.2243f
C546 a_92968_91054# VSS 3.93112f
C547 a_91900_91054# VSS 3.90351f
C548 a_90832_91054# VSS 5.23471f
C549 a_89764_91054# VSS 4.68749f
C550 a_88696_91054# VSS 3.6362f
C551 a_87628_91054# VSS 3.41078f
C552 a_86560_91054# VSS 4.50343f
C553 a_85492_91054# VSS 3.69571f
C554 a_84424_91054# VSS 3.5367f
C555 a_83356_91054# VSS 4.36699f
C556 a_82288_91054# VSS 3.77529f
C557 a_81220_91054# VSS 4.50674f
C558 a_80152_91054# VSS 3.8859f
C559 a_79084_91054# VSS 3.5515f
C560 a_78016_90254# VSS 4.46223f
C561 a_76948_90254# VSS 4.23258f
C562 a_75880_90254# VSS 4.38204f
C563 a_74812_90254# VSS 4.52145f
C564 a_73744_90254# VSS 4.22946f
C565 a_72676_90254# VSS 4.2378f
C566 a_71608_90254# VSS 4.2058f
C567 a_70540_90254# VSS 4.09517f
C568 a_69448_96914# VSS 4.10477f
C569 a_68216_96914# VSS 4.20114f
C570 a_2245_90628# VSS 0.24972p
C571 a_4789_117064# VSS 8.91806f
C572 a_3813_117064# VSS 5.17875f
C573 a_1005_131545# VSS 98.15211f
C574 a_13878_131545# VSS 0.07835f
C575 a_1005_131825# VSS 0.07377f
C576 a_13878_132105# VSS 0.07394f
C577 a_1005_132385# VSS 0.07377f
C578 a_13878_132665# VSS 0.07394f
C579 a_1005_132945# VSS 0.07377f
C580 a_13878_133225# VSS 0.07394f
C581 a_1005_133505# VSS 0.07377f
C582 a_13878_133785# VSS 0.07394f
C583 a_1005_134065# VSS 0.07377f
C584 a_13878_134345# VSS 0.07838f
C585 a_94036_152846# VSS 5.2243f
C586 a_92968_152846# VSS 3.93112f
C587 a_91900_152846# VSS 3.90351f
C588 a_90832_152846# VSS 5.23471f
C589 a_89764_152846# VSS 4.68749f
C590 a_88696_152846# VSS 3.6362f
C591 a_87628_152846# VSS 3.41078f
C592 a_86560_152846# VSS 4.50343f
C593 a_85492_152846# VSS 3.69571f
C594 a_84424_152846# VSS 3.5367f
C595 a_83356_152846# VSS 4.36699f
C596 a_82288_152846# VSS 3.77529f
C597 a_81220_152846# VSS 4.50674f
C598 a_80152_152846# VSS 3.8859f
C599 a_79084_152846# VSS 3.5515f
C600 a_78016_152046# VSS 4.46223f
C601 a_76948_152046# VSS 4.23258f
C602 a_75880_152046# VSS 4.38204f
C603 a_74812_152046# VSS 4.52145f
C604 a_73744_152046# VSS 4.22946f
C605 a_72676_152046# VSS 4.2378f
C606 a_71608_152046# VSS 4.2058f
C607 a_70540_152046# VSS 4.09517f
C608 a_69448_149284# VSS 4.10477f
C609 a_68216_149284# VSS 4.20114f
C610 a_1852_148519# VSS 0.41778p
C611 w_71178_112088# VSS 50.1311f
DWELL_ARRAY VSS ESD_RAIL diode_nw2ps_06v0 area=1138.9056p pj=941.44u
* netres.py resistances (high metal): 2091 resistors, res/f6.json res/f6_tu.json
RNR0 TERM_VCM TERM_VCM__P0 159.695
RNR1 TERM_VCM TERM_VCM__P1 158.938
RNR2 TERM_VCM TERM_VCM__P2 157.678
RNR3 TERM_VCM TERM_VCM__P3 155.825
RNR4 TERM_VCM TERM_VCM__P4 153.513
RNR5 TERM_VCM TERM_VCM__P5 150.611
RNR6 TERM_VCM TERM_VCM__P6 147.364
RNR7 TERM_VCM TERM_VCM__P7 143.726
RNR8 TERM_VCM TERM_VCM__P8 139.597
RNR9 TERM_VCM TERM_VCM__P9 135.328
RNR10 TERM_VCM TERM_VCM__P10 131.9
RNR11 TERM_VCM TERM_VCM__P11 127.082
RNR12 TERM_VCM TERM_VCM__P12 122.292
RNR13 TERM_VCM TERM_VCM__P13 117.414
RNR14 TERM_VCM TERM_VCM__P14 112.328
RNR15 TERM_VCM TERM_VCM__P15 107.441
RNR16 TERM_VCM TERM_VCM__P16 102.423
RNR17 TERM_VCM TERM_VCM__P17 97.6627
RNR18 TERM_VCM TERM_VCM__P18 93.0026
RNR19 TERM_VCM TERM_VCM__P19 88.3019
RNR20 TERM_VCM TERM_VCM__P20 83.9314
RNR21 TERM_VCM TERM_VCM__P21 79.7356
RNR22 TERM_VCM TERM_VCM__P22 75.6145
RNR23 TERM_VCM TERM_VCM__P23 71.9445
RNR24 TERM_VCM TERM_VCM__P24 68.6832
RNR25 TERM_VCM TERM_VCM__N0 159.675
RNR26 TERM_VCM TERM_VCM__N1 158.918
RNR27 TERM_VCM TERM_VCM__N2 157.658
RNR28 TERM_VCM TERM_VCM__N3 155.806
RNR29 TERM_VCM TERM_VCM__N4 153.495
RNR30 TERM_VCM TERM_VCM__N5 150.592
RNR31 TERM_VCM TERM_VCM__N6 147.346
RNR32 TERM_VCM TERM_VCM__N7 143.708
RNR33 TERM_VCM TERM_VCM__N8 139.58
RNR34 TERM_VCM TERM_VCM__N9 135.311
RNR35 TERM_VCM TERM_VCM__N10 131.873
RNR36 TERM_VCM TERM_VCM__N11 127.056
RNR37 TERM_VCM TERM_VCM__N12 122.266
RNR38 TERM_VCM TERM_VCM__N13 117.389
RNR39 TERM_VCM TERM_VCM__N14 112.304
RNR40 TERM_VCM TERM_VCM__N15 107.418
RNR41 TERM_VCM TERM_VCM__N16 102.401
RNR42 TERM_VCM TERM_VCM__N17 97.6419
RNR43 TERM_VCM TERM_VCM__N18 92.9826
RNR44 TERM_VCM TERM_VCM__N19 88.2829
RNR45 TERM_VCM TERM_VCM__N20 83.9132
RNR46 TERM_VCM TERM_VCM__N21 79.7181
RNR47 TERM_VCM TERM_VCM__N22 75.5978
RNR48 TERM_VCM TERM_VCM__N23 71.9284
RNR49 TERM_VCM TERM_VCM__N24 68.6676
RNR50 TERM_VCM__P0 TERM_VCM__P1 116.828
RNR51 TERM_VCM__P0 TERM_VCM__P2 125.764
RNR52 TERM_VCM__P0 TERM_VCM__P3 134.577
RNR53 TERM_VCM__P0 TERM_VCM__P4 143.147
RNR54 TERM_VCM__P0 TERM_VCM__P5 152.221
RNR55 TERM_VCM__P0 TERM_VCM__P6 161.292
RNR56 TERM_VCM__P0 TERM_VCM__P7 170.697
RNR57 TERM_VCM__P0 TERM_VCM__P8 180.841
RNR58 TERM_VCM__P0 TERM_VCM__P9 191.014
RNR59 TERM_VCM__P0 TERM_VCM__P10 203.197
RNR60 TERM_VCM__P0 TERM_VCM__P11 214.739
RNR61 TERM_VCM__P0 TERM_VCM__P12 226.217
RNR62 TERM_VCM__P0 TERM_VCM__P13 238.007
RNR63 TERM_VCM__P0 TERM_VCM__P14 250.569
RNR64 TERM_VCM__P0 TERM_VCM__P15 262.962
RNR65 TERM_VCM__P0 TERM_VCM__P16 276.044
RNR66 TERM_VCM__P0 TERM_VCM__P17 288.799
RNR67 TERM_VCM__P0 TERM_VCM__P18 301.602
RNR68 TERM_VCM__P0 TERM_VCM__P19 314.836
RNR69 TERM_VCM__P0 TERM_VCM__P20 327.437
RNR70 TERM_VCM__P0 TERM_VCM__P21 339.697
RNR71 TERM_VCM__P0 TERM_VCM__P22 351.887
RNR72 TERM_VCM__P0 TERM_VCM__P23 362.813
RNR73 TERM_VCM__P0 TERM_VCM__P24 372.392
RNR74 TERM_VCM__P0 TERM_VCM__N0 2286.5
RNR75 TERM_VCM__P0 TERM_VCM__N1 2363.01
RNR76 TERM_VCM__P0 TERM_VCM__N2 2404
RNR77 TERM_VCM__P0 TERM_VCM__N3 2420.42
RNR78 TERM_VCM__P0 TERM_VCM__N4 2419.67
RNR79 TERM_VCM__P0 TERM_VCM__N5 2404.53
RNR80 TERM_VCM__P0 TERM_VCM__N6 2379.03
RNR81 TERM_VCM__P0 TERM_VCM__N7 2344.08
RNR82 TERM_VCM__P0 TERM_VCM__N8 2299.22
RNR83 TERM_VCM__P0 TERM_VCM__N9 2248.77
RNR84 TERM_VCM__P0 TERM_VCM__N10 2209.94
RNR85 TERM_VCM__P0 TERM_VCM__N11 2146.4
RNR86 TERM_VCM__P0 TERM_VCM__N12 2080.46
RNR87 TERM_VCM__P0 TERM_VCM__N13 2010.92
RNR88 TERM_VCM__P0 TERM_VCM__N14 1936.22
RNR89 TERM_VCM__P0 TERM_VCM__N15 1862.56
RNR90 TERM_VCM__P0 TERM_VCM__N16 1785.22
RNR91 TERM_VCM__P0 TERM_VCM__N17 1710.39
RNR92 TERM_VCM__P0 TERM_VCM__N18 1635.86
RNR93 TERM_VCM__P0 TERM_VCM__N19 1559.53
RNR94 TERM_VCM__P0 TERM_VCM__N20 1487.6
RNR95 TERM_VCM__P0 TERM_VCM__N21 1417.74
RNR96 TERM_VCM__P0 TERM_VCM__N22 1348.41
RNR97 TERM_VCM__P0 TERM_VCM__N23 1286.12
RNR98 TERM_VCM__P0 TERM_VCM__N24 1230.34
RNR99 TERM_VCM__P1 TERM_VCM__P2 124.245
RNR100 TERM_VCM__P1 TERM_VCM__P3 133.374
RNR101 TERM_VCM__P1 TERM_VCM__P4 142.061
RNR102 TERM_VCM__P1 TERM_VCM__P5 151.17
RNR103 TERM_VCM__P1 TERM_VCM__P6 160.238
RNR104 TERM_VCM__P1 TERM_VCM__P7 169.617
RNR105 TERM_VCM__P1 TERM_VCM__P8 179.72
RNR106 TERM_VCM__P1 TERM_VCM__P9 189.843
RNR107 TERM_VCM__P1 TERM_VCM__P10 201.963
RNR108 TERM_VCM__P1 TERM_VCM__P11 213.441
RNR109 TERM_VCM__P1 TERM_VCM__P12 224.854
RNR110 TERM_VCM__P1 TERM_VCM__P13 236.577
RNR111 TERM_VCM__P1 TERM_VCM__P14 249.069
RNR112 TERM_VCM__P1 TERM_VCM__P15 261.393
RNR113 TERM_VCM__P1 TERM_VCM__P16 274.402
RNR114 TERM_VCM__P1 TERM_VCM__P17 287.087
RNR115 TERM_VCM__P1 TERM_VCM__P18 299.821
RNR116 TERM_VCM__P1 TERM_VCM__P19 312.985
RNR117 TERM_VCM__P1 TERM_VCM__P20 325.52
RNR118 TERM_VCM__P1 TERM_VCM__P21 337.718
RNR119 TERM_VCM__P1 TERM_VCM__P22 349.847
RNR120 TERM_VCM__P1 TERM_VCM__P23 360.721
RNR121 TERM_VCM__P1 TERM_VCM__P24 370.256
RNR122 TERM_VCM__P1 TERM_VCM__N0 2363
RNR123 TERM_VCM__P1 TERM_VCM__N1 2429.09
RNR124 TERM_VCM__P1 TERM_VCM__N2 2462.22
RNR125 TERM_VCM__P1 TERM_VCM__N3 2472.21
RNR126 TERM_VCM__P1 TERM_VCM__N4 2466.02
RNR127 TERM_VCM__P1 TERM_VCM__N5 2445.83
RNR128 TERM_VCM__P1 TERM_VCM__N6 2415.76
RNR129 TERM_VCM__P1 TERM_VCM__N7 2376.51
RNR130 TERM_VCM__P1 TERM_VCM__N8 2327.46
RNR131 TERM_VCM__P1 TERM_VCM__N9 2273.21
RNR132 TERM_VCM__P1 TERM_VCM__N10 2231.01
RNR133 TERM_VCM__P1 TERM_VCM__N11 2164.09
RNR134 TERM_VCM__P1 TERM_VCM__N12 2095.18
RNR135 TERM_VCM__P1 TERM_VCM__N13 2022.95
RNR136 TERM_VCM__P1 TERM_VCM__N14 1945.77
RNR137 TERM_VCM__P1 TERM_VCM__N15 1870.01
RNR138 TERM_VCM__P1 TERM_VCM__N16 1790.76
RNR139 TERM_VCM__P1 TERM_VCM__N17 1714.35
RNR140 TERM_VCM__P1 TERM_VCM__N18 1638.47
RNR141 TERM_VCM__P1 TERM_VCM__N19 1560.96
RNR142 TERM_VCM__P1 TERM_VCM__N20 1488.09
RNR143 TERM_VCM__P1 TERM_VCM__N21 1417.45
RNR144 TERM_VCM__P1 TERM_VCM__N22 1347.47
RNR145 TERM_VCM__P1 TERM_VCM__N23 1284.69
RNR146 TERM_VCM__P1 TERM_VCM__N24 1228.56
RNR147 TERM_VCM__P2 TERM_VCM__P3 130.978
RNR148 TERM_VCM__P2 TERM_VCM__P4 140.162
RNR149 TERM_VCM__P2 TERM_VCM__P5 149.468
RNR150 TERM_VCM__P2 TERM_VCM__P6 158.613
RNR151 TERM_VCM__P2 TERM_VCM__P7 167.999
RNR152 TERM_VCM__P2 TERM_VCM__P8 178.065
RNR153 TERM_VCM__P2 TERM_VCM__P9 188.132
RNR154 TERM_VCM__P2 TERM_VCM__P10 200.17
RNR155 TERM_VCM__P2 TERM_VCM__P11 211.558
RNR156 TERM_VCM__P2 TERM_VCM__P12 222.879
RNR157 TERM_VCM__P2 TERM_VCM__P13 234.506
RNR158 TERM_VCM__P2 TERM_VCM__P14 246.893
RNR159 TERM_VCM__P2 TERM_VCM__P15 259.113
RNR160 TERM_VCM__P2 TERM_VCM__P16 272.013
RNR161 TERM_VCM__P2 TERM_VCM__P17 284.592
RNR162 TERM_VCM__P2 TERM_VCM__P18 297.219
RNR163 TERM_VCM__P2 TERM_VCM__P19 310.275
RNR164 TERM_VCM__P2 TERM_VCM__P20 322.707
RNR165 TERM_VCM__P2 TERM_VCM__P21 334.805
RNR166 TERM_VCM__P2 TERM_VCM__P22 346.837
RNR167 TERM_VCM__P2 TERM_VCM__P23 357.624
RNR168 TERM_VCM__P2 TERM_VCM__P24 367.084
RNR169 TERM_VCM__P2 TERM_VCM__N0 2404
RNR170 TERM_VCM__P2 TERM_VCM__N1 2462.21
RNR171 TERM_VCM__P2 TERM_VCM__N2 2489.58
RNR172 TERM_VCM__P2 TERM_VCM__N3 2495.03
RNR173 TERM_VCM__P2 TERM_VCM__N4 2485.09
RNR174 TERM_VCM__P2 TERM_VCM__N5 2461.52
RNR175 TERM_VCM__P2 TERM_VCM__N6 2428.48
RNR176 TERM_VCM__P2 TERM_VCM__N7 2386.51
RNR177 TERM_VCM__P2 TERM_VCM__N8 2334.86
RNR178 TERM_VCM__P2 TERM_VCM__N9 2278.32
RNR179 TERM_VCM__P2 TERM_VCM__N10 2234.07
RNR180 TERM_VCM__P2 TERM_VCM__N11 2165.22
RNR181 TERM_VCM__P2 TERM_VCM__N12 2094.67
RNR182 TERM_VCM__P2 TERM_VCM__N13 2021.01
RNR183 TERM_VCM__P2 TERM_VCM__N14 1942.57
RNR184 TERM_VCM__P2 TERM_VCM__N15 1865.79
RNR185 TERM_VCM__P2 TERM_VCM__N16 1785.68
RNR186 TERM_VCM__P2 TERM_VCM__N17 1708.6
RNR187 TERM_VCM__P2 TERM_VCM__N18 1632.21
RNR188 TERM_VCM__P2 TERM_VCM__N19 1554.31
RNR189 TERM_VCM__P2 TERM_VCM__N20 1481.18
RNR190 TERM_VCM__P2 TERM_VCM__N21 1410.37
RNR191 TERM_VCM__P2 TERM_VCM__N22 1340.32
RNR192 TERM_VCM__P2 TERM_VCM__N23 1277.53
RNR193 TERM_VCM__P2 TERM_VCM__N24 1221.43
RNR194 TERM_VCM__P3 TERM_VCM__P4 136.963
RNR195 TERM_VCM__P3 TERM_VCM__P5 146.836
RNR196 TERM_VCM__P3 TERM_VCM__P6 156.207
RNR197 TERM_VCM__P3 TERM_VCM__P7 165.661
RNR198 TERM_VCM__P3 TERM_VCM__P8 175.708
RNR199 TERM_VCM__P3 TERM_VCM__P9 185.715
RNR200 TERM_VCM__P3 TERM_VCM__P10 197.652
RNR201 TERM_VCM__P3 TERM_VCM__P11 208.919
RNR202 TERM_VCM__P3 TERM_VCM__P12 220.113
RNR203 TERM_VCM__P3 TERM_VCM__P13 231.604
RNR204 TERM_VCM__P3 TERM_VCM__P14 243.844
RNR205 TERM_VCM__P3 TERM_VCM__P15 255.918
RNR206 TERM_VCM__P3 TERM_VCM__P16 268.662
RNR207 TERM_VCM__P3 TERM_VCM__P17 281.091
RNR208 TERM_VCM__P3 TERM_VCM__P18 293.566
RNR209 TERM_VCM__P3 TERM_VCM__P19 306.465
RNR210 TERM_VCM__P3 TERM_VCM__P20 318.749
RNR211 TERM_VCM__P3 TERM_VCM__P21 330.703
RNR212 TERM_VCM__P3 TERM_VCM__P22 342.592
RNR213 TERM_VCM__P3 TERM_VCM__P23 353.252
RNR214 TERM_VCM__P3 TERM_VCM__P24 362.602
RNR215 TERM_VCM__P3 TERM_VCM__N0 2420.42
RNR216 TERM_VCM__P3 TERM_VCM__N1 2472.21
RNR217 TERM_VCM__P3 TERM_VCM__N2 2495.03
RNR218 TERM_VCM__P3 TERM_VCM__N3 2496.99
RNR219 TERM_VCM__P3 TERM_VCM__N4 2484.31
RNR220 TERM_VCM__P3 TERM_VCM__N5 2458.35
RNR221 TERM_VCM__P3 TERM_VCM__N6 2423.29
RNR222 TERM_VCM__P3 TERM_VCM__N7 2379.55
RNR223 TERM_VCM__P3 TERM_VCM__N8 2326.3
RNR224 TERM_VCM__P3 TERM_VCM__N9 2268.41
RNR225 TERM_VCM__P3 TERM_VCM__N10 2222.92
RNR226 TERM_VCM__P3 TERM_VCM__N11 2153.07
RNR227 TERM_VCM__P3 TERM_VCM__N12 2081.73
RNR228 TERM_VCM__P3 TERM_VCM__N13 2007.48
RNR229 TERM_VCM__P3 TERM_VCM__N14 1928.59
RNR230 TERM_VCM__P3 TERM_VCM__N15 1851.53
RNR231 TERM_VCM__P3 TERM_VCM__N16 1771.28
RNR232 TERM_VCM__P3 TERM_VCM__N17 1694.19
RNR233 TERM_VCM__P3 TERM_VCM__N18 1617.89
RNR234 TERM_VCM__P3 TERM_VCM__N19 1540.17
RNR235 TERM_VCM__P3 TERM_VCM__N20 1467.29
RNR236 TERM_VCM__P3 TERM_VCM__N21 1396.8
RNR237 TERM_VCM__P3 TERM_VCM__N22 1327.11
RNR238 TERM_VCM__P3 TERM_VCM__N23 1264.69
RNR239 TERM_VCM__P3 TERM_VCM__N24 1208.96
RNR240 TERM_VCM__P4 TERM_VCM__P5 142.967
RNR241 TERM_VCM__P4 TERM_VCM__P6 152.946
RNR242 TERM_VCM__P4 TERM_VCM__P7 162.627
RNR243 TERM_VCM__P4 TERM_VCM__P8 172.725
RNR244 TERM_VCM__P4 TERM_VCM__P9 182.699
RNR245 TERM_VCM__P4 TERM_VCM__P10 194.539
RNR246 TERM_VCM__P4 TERM_VCM__P11 205.671
RNR247 TERM_VCM__P4 TERM_VCM__P12 216.717
RNR248 TERM_VCM__P4 TERM_VCM__P13 228.046
RNR249 TERM_VCM__P4 TERM_VCM__P14 240.108
RNR250 TERM_VCM__P4 TERM_VCM__P15 252.003
RNR251 TERM_VCM__P4 TERM_VCM__P16 264.557
RNR252 TERM_VCM__P4 TERM_VCM__P17 276.799
RNR253 TERM_VCM__P4 TERM_VCM__P18 289.088
RNR254 TERM_VCM__P4 TERM_VCM__P19 301.793
RNR255 TERM_VCM__P4 TERM_VCM__P20 313.893
RNR256 TERM_VCM__P4 TERM_VCM__P21 325.668
RNR257 TERM_VCM__P4 TERM_VCM__P22 337.381
RNR258 TERM_VCM__P4 TERM_VCM__P23 347.883
RNR259 TERM_VCM__P4 TERM_VCM__P24 357.094
RNR260 TERM_VCM__P4 TERM_VCM__N0 2419.67
RNR261 TERM_VCM__P4 TERM_VCM__N1 2466.02
RNR262 TERM_VCM__P4 TERM_VCM__N2 2485.09
RNR263 TERM_VCM__P4 TERM_VCM__N3 2484.3
RNR264 TERM_VCM__P4 TERM_VCM__N4 2469.53
RNR265 TERM_VCM__P4 TERM_VCM__N5 2441.85
RNR266 TERM_VCM__P4 TERM_VCM__N6 2405.42
RNR267 TERM_VCM__P4 TERM_VCM__N7 2360.55
RNR268 TERM_VCM__P4 TERM_VCM__N8 2306.36
RNR269 TERM_VCM__P4 TERM_VCM__N9 2247.76
RNR270 TERM_VCM__P4 TERM_VCM__N10 2201.57
RNR271 TERM_VCM__P4 TERM_VCM__N11 2131.35
RNR272 TERM_VCM__P4 TERM_VCM__N12 2059.83
RNR273 TERM_VCM__P4 TERM_VCM__N13 1985.55
RNR274 TERM_VCM__P4 TERM_VCM__N14 1906.77
RNR275 TERM_VCM__P4 TERM_VCM__N15 1829.95
RNR276 TERM_VCM__P4 TERM_VCM__N16 1750.05
RNR277 TERM_VCM__P4 TERM_VCM__N17 1673.39
RNR278 TERM_VCM__P4 TERM_VCM__N18 1597.6
RNR279 TERM_VCM__P4 TERM_VCM__N19 1520.48
RNR280 TERM_VCM__P4 TERM_VCM__N20 1448.21
RNR281 TERM_VCM__P4 TERM_VCM__N21 1378.37
RNR282 TERM_VCM__P4 TERM_VCM__N22 1309.36
RNR283 TERM_VCM__P4 TERM_VCM__N23 1247.59
RNR284 TERM_VCM__P4 TERM_VCM__N24 1192.46
RNR285 TERM_VCM__P5 TERM_VCM__P6 148.25
RNR286 TERM_VCM__P5 TERM_VCM__P7 158.557
RNR287 TERM_VCM__P5 TERM_VCM__P8 168.858
RNR288 TERM_VCM__P5 TERM_VCM__P9 178.861
RNR289 TERM_VCM__P5 TERM_VCM__P10 190.621
RNR290 TERM_VCM__P5 TERM_VCM__P11 201.606
RNR291 TERM_VCM__P5 TERM_VCM__P12 212.479
RNR292 TERM_VCM__P5 TERM_VCM__P13 223.614
RNR293 TERM_VCM__P5 TERM_VCM__P14 235.457
RNR294 TERM_VCM__P5 TERM_VCM__P15 247.132
RNR295 TERM_VCM__P5 TERM_VCM__P16 259.45
RNR296 TERM_VCM__P5 TERM_VCM__P17 271.461
RNR297 TERM_VCM__P5 TERM_VCM__P18 283.516
RNR298 TERM_VCM__P5 TERM_VCM__P19 295.98
RNR299 TERM_VCM__P5 TERM_VCM__P20 307.85
RNR300 TERM_VCM__P5 TERM_VCM__P21 319.402
RNR301 TERM_VCM__P5 TERM_VCM__P22 330.892
RNR302 TERM_VCM__P5 TERM_VCM__P23 341.195
RNR303 TERM_VCM__P5 TERM_VCM__P24 350.232
RNR304 TERM_VCM__P5 TERM_VCM__N0 2404.53
RNR305 TERM_VCM__P5 TERM_VCM__N1 2445.82
RNR306 TERM_VCM__P5 TERM_VCM__N2 2461.52
RNR307 TERM_VCM__P5 TERM_VCM__N3 2458.35
RNR308 TERM_VCM__P5 TERM_VCM__N4 2441.85
RNR309 TERM_VCM__P5 TERM_VCM__N5 2412.87
RNR310 TERM_VCM__P5 TERM_VCM__N6 2375.47
RNR311 TERM_VCM__P5 TERM_VCM__N7 2329.91
RNR312 TERM_VCM__P5 TERM_VCM__N8 2275.24
RNR313 TERM_VCM__P5 TERM_VCM__N9 2216.39
RNR314 TERM_VCM__P5 TERM_VCM__N10 2169.9
RNR315 TERM_VCM__P5 TERM_VCM__N11 2099.79
RNR316 TERM_VCM__P5 TERM_VCM__N12 2028.55
RNR317 TERM_VCM__P5 TERM_VCM__N13 1954.7
RNR318 TERM_VCM__P5 TERM_VCM__N14 1876.51
RNR319 TERM_VCM__P5 TERM_VCM__N15 1800.36
RNR320 TERM_VCM__P5 TERM_VCM__N16 1721.25
RNR321 TERM_VCM__P5 TERM_VCM__N17 1645.44
RNR322 TERM_VCM__P5 TERM_VCM__N18 1570.55
RNR323 TERM_VCM__P5 TERM_VCM__N19 1494.41
RNR324 TERM_VCM__P5 TERM_VCM__N20 1423.12
RNR325 TERM_VCM__P5 TERM_VCM__N21 1354.25
RNR326 TERM_VCM__P5 TERM_VCM__N22 1286.25
RNR327 TERM_VCM__P5 TERM_VCM__N23 1225.41
RNR328 TERM_VCM__P5 TERM_VCM__N24 1171.13
RNR329 TERM_VCM__P6 TERM_VCM__P7 153.213
RNR330 TERM_VCM__P6 TERM_VCM__P8 164.158
RNR331 TERM_VCM__P6 TERM_VCM__P9 174.374
RNR332 TERM_VCM__P6 TERM_VCM__P10 186.143
RNR333 TERM_VCM__P6 TERM_VCM__P11 197.015
RNR334 TERM_VCM__P6 TERM_VCM__P12 207.725
RNR335 TERM_VCM__P6 TERM_VCM__P13 218.66
RNR336 TERM_VCM__P6 TERM_VCM__P14 230.269
RNR337 TERM_VCM__P6 TERM_VCM__P15 241.704
RNR338 TERM_VCM__P6 TERM_VCM__P16 253.762
RNR339 TERM_VCM__P6 TERM_VCM__P17 265.517
RNR340 TERM_VCM__P6 TERM_VCM__P18 277.313
RNR341 TERM_VCM__P6 TERM_VCM__P19 289.508
RNR342 TERM_VCM__P6 TERM_VCM__P20 301.121
RNR343 TERM_VCM__P6 TERM_VCM__P21 312.424
RNR344 TERM_VCM__P6 TERM_VCM__P22 323.666
RNR345 TERM_VCM__P6 TERM_VCM__P23 333.747
RNR346 TERM_VCM__P6 TERM_VCM__P24 342.59
RNR347 TERM_VCM__P6 TERM_VCM__N0 2379.02
RNR348 TERM_VCM__P6 TERM_VCM__N1 2415.75
RNR349 TERM_VCM__P6 TERM_VCM__N2 2428.47
RNR350 TERM_VCM__P6 TERM_VCM__N3 2423.29
RNR351 TERM_VCM__P6 TERM_VCM__N4 2405.42
RNR352 TERM_VCM__P6 TERM_VCM__N5 2375.47
RNR353 TERM_VCM__P6 TERM_VCM__N6 2337.47
RNR354 TERM_VCM__P6 TERM_VCM__N7 2291.57
RNR355 TERM_VCM__P6 TERM_VCM__N8 2236.79
RNR356 TERM_VCM__P6 TERM_VCM__N9 2178.05
RNR357 TERM_VCM__P6 TERM_VCM__N10 2131.55
RNR358 TERM_VCM__P6 TERM_VCM__N11 2061.92
RNR359 TERM_VCM__P6 TERM_VCM__N12 1991.31
RNR360 TERM_VCM__P6 TERM_VCM__N13 1918.22
RNR361 TERM_VCM__P6 TERM_VCM__N14 1840.94
RNR362 TERM_VCM__P6 TERM_VCM__N15 1765.77
RNR363 TERM_VCM__P6 TERM_VCM__N16 1687.77
RNR364 TERM_VCM__P6 TERM_VCM__N17 1613.08
RNR365 TERM_VCM__P6 TERM_VCM__N18 1539.36
RNR366 TERM_VCM__P6 TERM_VCM__N19 1464.45
RNR367 TERM_VCM__P6 TERM_VCM__N20 1394.36
RNR368 TERM_VCM__P6 TERM_VCM__N21 1326.7
RNR369 TERM_VCM__P6 TERM_VCM__N22 1259.91
RNR370 TERM_VCM__P6 TERM_VCM__N23 1200.18
RNR371 TERM_VCM__P6 TERM_VCM__N24 1146.91
RNR372 TERM_VCM__P7 TERM_VCM__P8 158.074
RNR373 TERM_VCM__P7 TERM_VCM__P9 168.952
RNR374 TERM_VCM__P7 TERM_VCM__P10 180.922
RNR375 TERM_VCM__P7 TERM_VCM__P11 191.765
RNR376 TERM_VCM__P7 TERM_VCM__P12 202.348
RNR377 TERM_VCM__P7 TERM_VCM__P13 213.089
RNR378 TERM_VCM__P7 TERM_VCM__P14 224.453
RNR379 TERM_VCM__P7 TERM_VCM__P15 235.63
RNR380 TERM_VCM__P7 TERM_VCM__P16 247.403
RNR381 TERM_VCM__P7 TERM_VCM__P17 258.874
RNR382 TERM_VCM__P7 TERM_VCM__P18 270.382
RNR383 TERM_VCM__P7 TERM_VCM__P19 282.278
RNR384 TERM_VCM__P7 TERM_VCM__P20 293.605
RNR385 TERM_VCM__P7 TERM_VCM__P21 304.629
RNR386 TERM_VCM__P7 TERM_VCM__P22 315.593
RNR387 TERM_VCM__P7 TERM_VCM__P23 325.426
RNR388 TERM_VCM__P7 TERM_VCM__P24 334.05
RNR389 TERM_VCM__P7 TERM_VCM__N0 2344.07
RNR390 TERM_VCM__P7 TERM_VCM__N1 2376.51
RNR391 TERM_VCM__P7 TERM_VCM__N2 2386.5
RNR392 TERM_VCM__P7 TERM_VCM__N3 2379.55
RNR393 TERM_VCM__P7 TERM_VCM__N4 2360.55
RNR394 TERM_VCM__P7 TERM_VCM__N5 2329.91
RNR395 TERM_VCM__P7 TERM_VCM__N6 2291.57
RNR396 TERM_VCM__P7 TERM_VCM__N7 2245.61
RNR397 TERM_VCM__P7 TERM_VCM__N8 2191.03
RNR398 TERM_VCM__P7 TERM_VCM__N9 2132.7
RNR399 TERM_VCM__P7 TERM_VCM__N10 2086.43
RNR400 TERM_VCM__P7 TERM_VCM__N11 2017.6
RNR401 TERM_VCM__P7 TERM_VCM__N12 1947.92
RNR402 TERM_VCM__P7 TERM_VCM__N13 1875.9
RNR403 TERM_VCM__P7 TERM_VCM__N14 1799.84
RNR404 TERM_VCM__P7 TERM_VCM__N15 1725.94
RNR405 TERM_VCM__P7 TERM_VCM__N16 1649.32
RNR406 TERM_VCM__P7 TERM_VCM__N17 1576.02
RNR407 TERM_VCM__P7 TERM_VCM__N18 1503.72
RNR408 TERM_VCM__P7 TERM_VCM__N19 1430.3
RNR409 TERM_VCM__P7 TERM_VCM__N20 1361.64
RNR410 TERM_VCM__P7 TERM_VCM__N21 1295.39
RNR411 TERM_VCM__P7 TERM_VCM__N22 1230.03
RNR412 TERM_VCM__P7 TERM_VCM__N23 1171.6
RNR413 TERM_VCM__P7 TERM_VCM__N24 1119.5
RNR414 TERM_VCM__P8 TERM_VCM__P9 161.98
RNR415 TERM_VCM__P8 TERM_VCM__P10 174.622
RNR416 TERM_VCM__P8 TERM_VCM__P11 185.607
RNR417 TERM_VCM__P8 TERM_VCM__P12 196.143
RNR418 TERM_VCM__P8 TERM_VCM__P13 206.718
RNR419 TERM_VCM__P8 TERM_VCM__P14 217.832
RNR420 TERM_VCM__P8 TERM_VCM__P15 228.732
RNR421 TERM_VCM__P8 TERM_VCM__P16 240.191
RNR422 TERM_VCM__P8 TERM_VCM__P17 251.347
RNR423 TERM_VCM__P8 TERM_VCM__P18 262.532
RNR424 TERM_VCM__P8 TERM_VCM__P19 274.089
RNR425 TERM_VCM__P8 TERM_VCM__P20 285.093
RNR426 TERM_VCM__P8 TERM_VCM__P21 295.801
RNR427 TERM_VCM__P8 TERM_VCM__P22 306.451
RNR428 TERM_VCM__P8 TERM_VCM__P23 316.001
RNR429 TERM_VCM__P8 TERM_VCM__P24 324.378
RNR430 TERM_VCM__P8 TERM_VCM__N0 2299.22
RNR431 TERM_VCM__P8 TERM_VCM__N1 2327.45
RNR432 TERM_VCM__P8 TERM_VCM__N2 2334.86
RNR433 TERM_VCM__P8 TERM_VCM__N3 2326.29
RNR434 TERM_VCM__P8 TERM_VCM__N4 2306.35
RNR435 TERM_VCM__P8 TERM_VCM__N5 2275.24
RNR436 TERM_VCM__P8 TERM_VCM__N6 2236.79
RNR437 TERM_VCM__P8 TERM_VCM__N7 2191.03
RNR438 TERM_VCM__P8 TERM_VCM__N8 2136.92
RNR439 TERM_VCM__P8 TERM_VCM__N9 2079.29
RNR440 TERM_VCM__P8 TERM_VCM__N10 2033.5
RNR441 TERM_VCM__P8 TERM_VCM__N11 1965.78
RNR442 TERM_VCM__P8 TERM_VCM__N12 1897.34
RNR443 TERM_VCM__P8 TERM_VCM__N13 1826.7
RNR444 TERM_VCM__P8 TERM_VCM__N14 1752.18
RNR445 TERM_VCM__P8 TERM_VCM__N15 1679.86
RNR446 TERM_VCM__P8 TERM_VCM__N16 1604.94
RNR447 TERM_VCM__P8 TERM_VCM__N17 1533.31
RNR448 TERM_VCM__P8 TERM_VCM__N18 1462.72
RNR449 TERM_VCM__P8 TERM_VCM__N19 1391.08
RNR450 TERM_VCM__P8 TERM_VCM__N20 1324.12
RNR451 TERM_VCM__P8 TERM_VCM__N21 1259.53
RNR452 TERM_VCM__P8 TERM_VCM__N22 1195.84
RNR453 TERM_VCM__P8 TERM_VCM__N23 1138.92
RNR454 TERM_VCM__P8 TERM_VCM__N24 1088.18
RNR455 TERM_VCM__P9 TERM_VCM__P10 167.266
RNR456 TERM_VCM__P9 TERM_VCM__P11 178.777
RNR457 TERM_VCM__P9 TERM_VCM__P12 189.476
RNR458 TERM_VCM__P9 TERM_VCM__P13 199.996
RNR459 TERM_VCM__P9 TERM_VCM__P14 210.916
RNR460 TERM_VCM__P9 TERM_VCM__P15 221.565
RNR461 TERM_VCM__P9 TERM_VCM__P16 232.719
RNR462 TERM_VCM__P9 TERM_VCM__P17 243.56
RNR463 TERM_VCM__P9 TERM_VCM__P18 254.418
RNR464 TERM_VCM__P9 TERM_VCM__P19 265.63
RNR465 TERM_VCM__P9 TERM_VCM__P20 276.301
RNR466 TERM_VCM__P9 TERM_VCM__P21 286.684
RNR467 TERM_VCM__P9 TERM_VCM__P22 297.01
RNR468 TERM_VCM__P9 TERM_VCM__P23 306.269
RNR469 TERM_VCM__P9 TERM_VCM__P24 314.39
RNR470 TERM_VCM__P9 TERM_VCM__N0 2248.76
RNR471 TERM_VCM__P9 TERM_VCM__N1 2273.2
RNR472 TERM_VCM__P9 TERM_VCM__N2 2278.32
RNR473 TERM_VCM__P9 TERM_VCM__N3 2268.4
RNR474 TERM_VCM__P9 TERM_VCM__N4 2247.75
RNR475 TERM_VCM__P9 TERM_VCM__N5 2216.39
RNR476 TERM_VCM__P9 TERM_VCM__N6 2178.05
RNR477 TERM_VCM__P9 TERM_VCM__N7 2132.7
RNR478 TERM_VCM__P9 TERM_VCM__N8 2079.29
RNR479 TERM_VCM__P9 TERM_VCM__N9 2022.56
RNR480 TERM_VCM__P9 TERM_VCM__N10 1977.43
RNR481 TERM_VCM__P9 TERM_VCM__N11 1911.02
RNR482 TERM_VCM__P9 TERM_VCM__N12 1844
RNR483 TERM_VCM__P9 TERM_VCM__N13 1774.92
RNR484 TERM_VCM__P9 TERM_VCM__N14 1702.12
RNR485 TERM_VCM__P9 TERM_VCM__N15 1631.52
RNR486 TERM_VCM__P9 TERM_VCM__N16 1558.46
RNR487 TERM_VCM__P9 TERM_VCM__N17 1488.65
RNR488 TERM_VCM__P9 TERM_VCM__N18 1419.89
RNR489 TERM_VCM__P9 TERM_VCM__N19 1350.15
RNR490 TERM_VCM__P9 TERM_VCM__N20 1285
RNR491 TERM_VCM__P9 TERM_VCM__N21 1222.18
RNR492 TERM_VCM__P9 TERM_VCM__N22 1160.26
RNR493 TERM_VCM__P9 TERM_VCM__N23 1104.93
RNR494 TERM_VCM__P9 TERM_VCM__N24 1055.63
RNR495 TERM_VCM__P10 TERM_VCM__P11 170.815
RNR496 TERM_VCM__P10 TERM_VCM__P12 182.959
RNR497 TERM_VCM__P10 TERM_VCM__P13 194.056
RNR498 TERM_VCM__P10 TERM_VCM__P14 205.116
RNR499 TERM_VCM__P10 TERM_VCM__P15 215.695
RNR500 TERM_VCM__P10 TERM_VCM__P16 226.665
RNR501 TERM_VCM__P10 TERM_VCM__P17 237.281
RNR502 TERM_VCM__P10 TERM_VCM__P18 247.888
RNR503 TERM_VCM__P10 TERM_VCM__P19 258.828
RNR504 TERM_VCM__P10 TERM_VCM__P20 269.236
RNR505 TERM_VCM__P10 TERM_VCM__P21 279.359
RNR506 TERM_VCM__P10 TERM_VCM__P22 289.424
RNR507 TERM_VCM__P10 TERM_VCM__P23 298.449
RNR508 TERM_VCM__P10 TERM_VCM__P24 306.365
RNR509 TERM_VCM__P10 TERM_VCM__N0 2210.12
RNR510 TERM_VCM__P10 TERM_VCM__N1 2231.2
RNR511 TERM_VCM__P10 TERM_VCM__N2 2234.26
RNR512 TERM_VCM__P10 TERM_VCM__N3 2223.1
RNR513 TERM_VCM__P10 TERM_VCM__N4 2201.76
RNR514 TERM_VCM__P10 TERM_VCM__N5 2170.08
RNR515 TERM_VCM__P10 TERM_VCM__N6 2131.72
RNR516 TERM_VCM__P10 TERM_VCM__N7 2086.61
RNR517 TERM_VCM__P10 TERM_VCM__N8 2033.68
RNR518 TERM_VCM__P10 TERM_VCM__N9 1977.6
RNR519 TERM_VCM__P10 TERM_VCM__N10 1932.92
RNR520 TERM_VCM__P10 TERM_VCM__N11 1867.49
RNR521 TERM_VCM__P10 TERM_VCM__N12 1801.56
RNR522 TERM_VCM__P10 TERM_VCM__N13 1733.68
RNR523 TERM_VCM__P10 TERM_VCM__N14 1662.21
RNR524 TERM_VCM__P10 TERM_VCM__N15 1592.97
RNR525 TERM_VCM__P10 TERM_VCM__N16 1521.35
RNR526 TERM_VCM__P10 TERM_VCM__N17 1452.98
RNR527 TERM_VCM__P10 TERM_VCM__N18 1385.66
RNR528 TERM_VCM__P10 TERM_VCM__N19 1317.42
RNR529 TERM_VCM__P10 TERM_VCM__N20 1253.7
RNR530 TERM_VCM__P10 TERM_VCM__N21 1192.29
RNR531 TERM_VCM__P10 TERM_VCM__N22 1131.77
RNR532 TERM_VCM__P10 TERM_VCM__N23 1077.71
RNR533 TERM_VCM__P10 TERM_VCM__N24 1029.56
RNR534 TERM_VCM__P11 TERM_VCM__P12 173.188
RNR535 TERM_VCM__P11 TERM_VCM__P13 185.364
RNR536 TERM_VCM__P11 TERM_VCM__P14 196.779
RNR537 TERM_VCM__P11 TERM_VCM__P15 207.352
RNR538 TERM_VCM__P11 TERM_VCM__P16 218.115
RNR539 TERM_VCM__P11 TERM_VCM__P17 228.445
RNR540 TERM_VCM__P11 TERM_VCM__P18 238.717
RNR541 TERM_VCM__P11 TERM_VCM__P19 249.285
RNR542 TERM_VCM__P11 TERM_VCM__P20 259.327
RNR543 TERM_VCM__P11 TERM_VCM__P21 269.089
RNR544 TERM_VCM__P11 TERM_VCM__P22 278.79
RNR545 TERM_VCM__P11 TERM_VCM__P23 287.488
RNR546 TERM_VCM__P11 TERM_VCM__P24 295.115
RNR547 TERM_VCM__P11 TERM_VCM__N0 2146.58
RNR548 TERM_VCM__P11 TERM_VCM__N1 2164.27
RNR549 TERM_VCM__P11 TERM_VCM__N2 2165.4
RNR550 TERM_VCM__P11 TERM_VCM__N3 2153.24
RNR551 TERM_VCM__P11 TERM_VCM__N4 2131.53
RNR552 TERM_VCM__P11 TERM_VCM__N5 2099.97
RNR553 TERM_VCM__P11 TERM_VCM__N6 2062.09
RNR554 TERM_VCM__P11 TERM_VCM__N7 2017.77
RNR555 TERM_VCM__P11 TERM_VCM__N8 1965.95
RNR556 TERM_VCM__P11 TERM_VCM__N9 1911.18
RNR557 TERM_VCM__P11 TERM_VCM__N10 1867.49
RNR558 TERM_VCM__P11 TERM_VCM__N11 1803.81
RNR559 TERM_VCM__P11 TERM_VCM__N12 1739.72
RNR560 TERM_VCM__P11 TERM_VCM__N13 1673.8
RNR561 TERM_VCM__P11 TERM_VCM__N14 1604.47
RNR562 TERM_VCM__P11 TERM_VCM__N15 1537.35
RNR563 TERM_VCM__P11 TERM_VCM__N16 1467.98
RNR564 TERM_VCM__P11 TERM_VCM__N17 1401.79
RNR565 TERM_VCM__P11 TERM_VCM__N18 1336.66
RNR566 TERM_VCM__P11 TERM_VCM__N19 1270.67
RNR567 TERM_VCM__P11 TERM_VCM__N20 1209.07
RNR568 TERM_VCM__P11 TERM_VCM__N21 1149.72
RNR569 TERM_VCM__P11 TERM_VCM__N22 1091.26
RNR570 TERM_VCM__P11 TERM_VCM__N23 1039.06
RNR571 TERM_VCM__P11 TERM_VCM__N24 992.568
RNR572 TERM_VCM__P12 TERM_VCM__P13 175.238
RNR573 TERM_VCM__P12 TERM_VCM__P14 187.742
RNR574 TERM_VCM__P12 TERM_VCM__P15 198.678
RNR575 TERM_VCM__P12 TERM_VCM__P16 209.423
RNR576 TERM_VCM__P12 TERM_VCM__P17 219.563
RNR577 TERM_VCM__P12 TERM_VCM__P18 229.551
RNR578 TERM_VCM__P12 TERM_VCM__P19 239.774
RNR579 TERM_VCM__P12 TERM_VCM__P20 249.467
RNR580 TERM_VCM__P12 TERM_VCM__P21 258.876
RNR581 TERM_VCM__P12 TERM_VCM__P22 268.22
RNR582 TERM_VCM__P12 TERM_VCM__P23 276.593
RNR583 TERM_VCM__P12 TERM_VCM__P24 283.933
RNR584 TERM_VCM__P12 TERM_VCM__N0 2080.64
RNR585 TERM_VCM__P12 TERM_VCM__N1 2095.35
RNR586 TERM_VCM__P12 TERM_VCM__N2 2094.84
RNR587 TERM_VCM__P12 TERM_VCM__N3 2081.91
RNR588 TERM_VCM__P12 TERM_VCM__N4 2060
RNR589 TERM_VCM__P12 TERM_VCM__N5 2028.72
RNR590 TERM_VCM__P12 TERM_VCM__N6 1991.47
RNR591 TERM_VCM__P12 TERM_VCM__N7 1948.08
RNR592 TERM_VCM__P12 TERM_VCM__N8 1897.5
RNR593 TERM_VCM__P12 TERM_VCM__N9 1844.16
RNR594 TERM_VCM__P12 TERM_VCM__N10 1801.56
RNR595 TERM_VCM__P12 TERM_VCM__N11 1739.72
RNR596 TERM_VCM__P12 TERM_VCM__N12 1677.55
RNR597 TERM_VCM__P12 TERM_VCM__N13 1613.68
RNR598 TERM_VCM__P12 TERM_VCM__N14 1546.55
RNR599 TERM_VCM__P12 TERM_VCM__N15 1481.6
RNR600 TERM_VCM__P12 TERM_VCM__N16 1414.53
RNR601 TERM_VCM__P12 TERM_VCM__N17 1350.56
RNR602 TERM_VCM__P12 TERM_VCM__N18 1287.65
RNR603 TERM_VCM__P12 TERM_VCM__N19 1223.94
RNR604 TERM_VCM__P12 TERM_VCM__N20 1164.48
RNR605 TERM_VCM__P12 TERM_VCM__N21 1107.23
RNR606 TERM_VCM__P12 TERM_VCM__N22 1050.84
RNR607 TERM_VCM__P12 TERM_VCM__N23 1000.5
RNR608 TERM_VCM__P12 TERM_VCM__N24 955.679
RNR609 TERM_VCM__P13 TERM_VCM__P14 177.117
RNR610 TERM_VCM__P13 TERM_VCM__P15 189.124
RNR611 TERM_VCM__P13 TERM_VCM__P16 200.212
RNR612 TERM_VCM__P13 TERM_VCM__P17 210.338
RNR613 TERM_VCM__P13 TERM_VCM__P18 220.127
RNR614 TERM_VCM__P13 TERM_VCM__P19 230.046
RNR615 TERM_VCM__P13 TERM_VCM__P20 239.406
RNR616 TERM_VCM__P13 TERM_VCM__P21 248.468
RNR617 TERM_VCM__P13 TERM_VCM__P22 257.454
RNR618 TERM_VCM__P13 TERM_VCM__P23 265.5
RNR619 TERM_VCM__P13 TERM_VCM__P24 272.548
RNR620 TERM_VCM__P13 TERM_VCM__N0 2011.09
RNR621 TERM_VCM__P13 TERM_VCM__N1 2023.12
RNR622 TERM_VCM__P13 TERM_VCM__N2 2021.18
RNR623 TERM_VCM__P13 TERM_VCM__N3 2007.65
RNR624 TERM_VCM__P13 TERM_VCM__N4 1985.71
RNR625 TERM_VCM__P13 TERM_VCM__N5 1954.87
RNR626 TERM_VCM__P13 TERM_VCM__N6 1918.38
RNR627 TERM_VCM__P13 TERM_VCM__N7 1876.06
RNR628 TERM_VCM__P13 TERM_VCM__N8 1826.85
RNR629 TERM_VCM__P13 TERM_VCM__N9 1775.07
RNR630 TERM_VCM__P13 TERM_VCM__N10 1733.68
RNR631 TERM_VCM__P13 TERM_VCM__N11 1673.8
RNR632 TERM_VCM__P13 TERM_VCM__N12 1613.68
RNR633 TERM_VCM__P13 TERM_VCM__N13 1551.95
RNR634 TERM_VCM__P13 TERM_VCM__N14 1487.14
RNR635 TERM_VCM__P13 TERM_VCM__N15 1424.47
RNR636 TERM_VCM__P13 TERM_VCM__N16 1359.78
RNR637 TERM_VCM__P13 TERM_VCM__N17 1298.13
RNR638 TERM_VCM__P13 TERM_VCM__N18 1237.52
RNR639 TERM_VCM__P13 TERM_VCM__N19 1176.16
RNR640 TERM_VCM__P13 TERM_VCM__N20 1118.92
RNR641 TERM_VCM__P13 TERM_VCM__N21 1063.82
RNR642 TERM_VCM__P13 TERM_VCM__N22 1009.56
RNR643 TERM_VCM__P13 TERM_VCM__N23 961.136
RNR644 TERM_VCM__P13 TERM_VCM__N24 918.027
RNR645 TERM_VCM__P14 TERM_VCM__P15 177.714
RNR646 TERM_VCM__P14 TERM_VCM__P16 189.895
RNR647 TERM_VCM__P14 TERM_VCM__P17 200.367
RNR648 TERM_VCM__P14 TERM_VCM__P18 210.127
RNR649 TERM_VCM__P14 TERM_VCM__P19 219.817
RNR650 TERM_VCM__P14 TERM_VCM__P20 228.875
RNR651 TERM_VCM__P14 TERM_VCM__P21 237.598
RNR652 TERM_VCM__P14 TERM_VCM__P22 246.221
RNR653 TERM_VCM__P14 TERM_VCM__P23 253.931
RNR654 TERM_VCM__P14 TERM_VCM__P24 260.675
RNR655 TERM_VCM__P14 TERM_VCM__N0 1936.38
RNR656 TERM_VCM__P14 TERM_VCM__N1 1945.93
RNR657 TERM_VCM__P14 TERM_VCM__N2 1942.73
RNR658 TERM_VCM__P14 TERM_VCM__N3 1928.75
RNR659 TERM_VCM__P14 TERM_VCM__N4 1906.93
RNR660 TERM_VCM__P14 TERM_VCM__N5 1876.67
RNR661 TERM_VCM__P14 TERM_VCM__N6 1841.1
RNR662 TERM_VCM__P14 TERM_VCM__N7 1800
RNR663 TERM_VCM__P14 TERM_VCM__N8 1752.34
RNR664 TERM_VCM__P14 TERM_VCM__N9 1702.27
RNR665 TERM_VCM__P14 TERM_VCM__N10 1662.22
RNR666 TERM_VCM__P14 TERM_VCM__N11 1604.47
RNR667 TERM_VCM__P14 TERM_VCM__N12 1546.55
RNR668 TERM_VCM__P14 TERM_VCM__N13 1487.14
RNR669 TERM_VCM__P14 TERM_VCM__N14 1424.79
RNR670 TERM_VCM__P14 TERM_VCM__N15 1364.56
RNR671 TERM_VCM__P14 TERM_VCM__N16 1302.41
RNR672 TERM_VCM__P14 TERM_VCM__N17 1243.21
RNR673 TERM_VCM__P14 TERM_VCM__N18 1185.03
RNR674 TERM_VCM__P14 TERM_VCM__N19 1126.16
RNR675 TERM_VCM__P14 TERM_VCM__N20 1071.26
RNR676 TERM_VCM__P14 TERM_VCM__N21 1018.42
RNR677 TERM_VCM__P14 TERM_VCM__N22 966.406
RNR678 TERM_VCM__P14 TERM_VCM__N23 919.997
RNR679 TERM_VCM__P14 TERM_VCM__N24 878.687
RNR680 TERM_VCM__P15 TERM_VCM__P16 178.445
RNR681 TERM_VCM__P15 TERM_VCM__P17 190.007
RNR682 TERM_VCM__P15 TERM_VCM__P18 200.122
RNR683 TERM_VCM__P15 TERM_VCM__P19 209.787
RNR684 TERM_VCM__P15 TERM_VCM__P20 218.651
RNR685 TERM_VCM__P15 TERM_VCM__P21 227.098
RNR686 TERM_VCM__P15 TERM_VCM__P22 235.396
RNR687 TERM_VCM__P15 TERM_VCM__P23 242.794
RNR688 TERM_VCM__P15 TERM_VCM__P24 249.248
RNR689 TERM_VCM__P15 TERM_VCM__N0 1862.72
RNR690 TERM_VCM__P15 TERM_VCM__N1 1870.16
RNR691 TERM_VCM__P15 TERM_VCM__N2 1865.95
RNR692 TERM_VCM__P15 TERM_VCM__N3 1851.69
RNR693 TERM_VCM__P15 TERM_VCM__N4 1830.1
RNR694 TERM_VCM__P15 TERM_VCM__N5 1800.51
RNR695 TERM_VCM__P15 TERM_VCM__N6 1765.93
RNR696 TERM_VCM__P15 TERM_VCM__N7 1726.09
RNR697 TERM_VCM__P15 TERM_VCM__N8 1680
RNR698 TERM_VCM__P15 TERM_VCM__N9 1631.67
RNR699 TERM_VCM__P15 TERM_VCM__N10 1592.97
RNR700 TERM_VCM__P15 TERM_VCM__N11 1537.35
RNR701 TERM_VCM__P15 TERM_VCM__N12 1481.61
RNR702 TERM_VCM__P15 TERM_VCM__N13 1424.47
RNR703 TERM_VCM__P15 TERM_VCM__N14 1364.56
RNR704 TERM_VCM__P15 TERM_VCM__N15 1306.7
RNR705 TERM_VCM__P15 TERM_VCM__N16 1247.03
RNR706 TERM_VCM__P15 TERM_VCM__N17 1190.22
RNR707 TERM_VCM__P15 TERM_VCM__N18 1134.42
RNR708 TERM_VCM__P15 TERM_VCM__N19 1077.96
RNR709 TERM_VCM__P15 TERM_VCM__N20 1025.33
RNR710 TERM_VCM__P15 TERM_VCM__N21 974.685
RNR711 TERM_VCM__P15 TERM_VCM__N22 924.845
RNR712 TERM_VCM__P15 TERM_VCM__N23 880.384
RNR713 TERM_VCM__P15 TERM_VCM__N24 840.815
RNR714 TERM_VCM__P16 TERM_VCM__P17 177.908
RNR715 TERM_VCM__P16 TERM_VCM__P18 189.121
RNR716 TERM_VCM__P16 TERM_VCM__P19 199.134
RNR717 TERM_VCM__P16 TERM_VCM__P20 207.977
RNR718 TERM_VCM__P16 TERM_VCM__P21 216.227
RNR719 TERM_VCM__P16 TERM_VCM__P22 224.234
RNR720 TERM_VCM__P16 TERM_VCM__P23 231.329
RNR721 TERM_VCM__P16 TERM_VCM__P24 237.49
RNR722 TERM_VCM__P16 TERM_VCM__N0 1785.37
RNR723 TERM_VCM__P16 TERM_VCM__N1 1790.91
RNR724 TERM_VCM__P16 TERM_VCM__N2 1785.83
RNR725 TERM_VCM__P16 TERM_VCM__N3 1771.43
RNR726 TERM_VCM__P16 TERM_VCM__N4 1750.2
RNR727 TERM_VCM__P16 TERM_VCM__N5 1721.4
RNR728 TERM_VCM__P16 TERM_VCM__N6 1687.92
RNR729 TERM_VCM__P16 TERM_VCM__N7 1649.47
RNR730 TERM_VCM__P16 TERM_VCM__N8 1605.08
RNR731 TERM_VCM__P16 TERM_VCM__N9 1558.59
RNR732 TERM_VCM__P16 TERM_VCM__N10 1521.36
RNR733 TERM_VCM__P16 TERM_VCM__N11 1467.98
RNR734 TERM_VCM__P16 TERM_VCM__N12 1414.53
RNR735 TERM_VCM__P16 TERM_VCM__N13 1359.78
RNR736 TERM_VCM__P16 TERM_VCM__N14 1302.41
RNR737 TERM_VCM__P16 TERM_VCM__N15 1247.04
RNR738 TERM_VCM__P16 TERM_VCM__N16 1189.96
RNR739 TERM_VCM__P16 TERM_VCM__N17 1135.63
RNR740 TERM_VCM__P16 TERM_VCM__N18 1082.29
RNR741 TERM_VCM__P16 TERM_VCM__N19 1028.33
RNR742 TERM_VCM__P16 TERM_VCM__N20 978.053
RNR743 TERM_VCM__P16 TERM_VCM__N21 929.684
RNR744 TERM_VCM__P16 TERM_VCM__N22 882.091
RNR745 TERM_VCM__P16 TERM_VCM__N23 839.642
RNR746 TERM_VCM__P16 TERM_VCM__N24 801.87
RNR747 TERM_VCM__P17 TERM_VCM__P18 177.154
RNR748 TERM_VCM__P17 TERM_VCM__P19 188.262
RNR749 TERM_VCM__P17 TERM_VCM__P20 197.461
RNR750 TERM_VCM__P17 TERM_VCM__P21 205.712
RNR751 TERM_VCM__P17 TERM_VCM__P22 213.533
RNR752 TERM_VCM__P17 TERM_VCM__P23 220.382
RNR753 TERM_VCM__P17 TERM_VCM__P24 226.274
RNR754 TERM_VCM__P17 TERM_VCM__N0 1710.53
RNR755 TERM_VCM__P17 TERM_VCM__N1 1714.5
RNR756 TERM_VCM__P17 TERM_VCM__N2 1708.75
RNR757 TERM_VCM__P17 TERM_VCM__N3 1694.34
RNR758 TERM_VCM__P17 TERM_VCM__N4 1673.54
RNR759 TERM_VCM__P17 TERM_VCM__N5 1645.59
RNR760 TERM_VCM__P17 TERM_VCM__N6 1613.22
RNR761 TERM_VCM__P17 TERM_VCM__N7 1576.16
RNR762 TERM_VCM__P17 TERM_VCM__N8 1533.45
RNR763 TERM_VCM__P17 TERM_VCM__N9 1488.79
RNR764 TERM_VCM__P17 TERM_VCM__N10 1452.98
RNR765 TERM_VCM__P17 TERM_VCM__N11 1401.79
RNR766 TERM_VCM__P17 TERM_VCM__N12 1350.57
RNR767 TERM_VCM__P17 TERM_VCM__N13 1298.13
RNR768 TERM_VCM__P17 TERM_VCM__N14 1243.21
RNR769 TERM_VCM__P17 TERM_VCM__N15 1190.22
RNR770 TERM_VCM__P17 TERM_VCM__N16 1135.63
RNR771 TERM_VCM__P17 TERM_VCM__N17 1083.69
RNR772 TERM_VCM__P17 TERM_VCM__N18 1032.7
RNR773 TERM_VCM__P17 TERM_VCM__N19 981.146
RNR774 TERM_VCM__P17 TERM_VCM__N20 933.112
RNR775 TERM_VCM__P17 TERM_VCM__N21 886.914
RNR776 TERM_VCM__P17 TERM_VCM__N22 841.465
RNR777 TERM_VCM__P17 TERM_VCM__N23 800.935
RNR778 TERM_VCM__P17 TERM_VCM__N24 764.875
RNR779 TERM_VCM__P18 TERM_VCM__P19 176.152
RNR780 TERM_VCM__P18 TERM_VCM__P20 186.421
RNR781 TERM_VCM__P18 TERM_VCM__P21 195.035
RNR782 TERM_VCM__P18 TERM_VCM__P22 202.849
RNR783 TERM_VCM__P18 TERM_VCM__P23 209.533
RNR784 TERM_VCM__P18 TERM_VCM__P24 215.182
RNR785 TERM_VCM__P18 TERM_VCM__N0 1636
RNR786 TERM_VCM__P18 TERM_VCM__N1 1638.61
RNR787 TERM_VCM__P18 TERM_VCM__N2 1632.36
RNR788 TERM_VCM__P18 TERM_VCM__N3 1618.03
RNR789 TERM_VCM__P18 TERM_VCM__N4 1597.74
RNR790 TERM_VCM__P18 TERM_VCM__N5 1570.69
RNR791 TERM_VCM__P18 TERM_VCM__N6 1539.5
RNR792 TERM_VCM__P18 TERM_VCM__N7 1503.85
RNR793 TERM_VCM__P18 TERM_VCM__N8 1462.85
RNR794 TERM_VCM__P18 TERM_VCM__N9 1420.02
RNR795 TERM_VCM__P18 TERM_VCM__N10 1385.67
RNR796 TERM_VCM__P18 TERM_VCM__N11 1336.67
RNR797 TERM_VCM__P18 TERM_VCM__N12 1287.66
RNR798 TERM_VCM__P18 TERM_VCM__N13 1237.52
RNR799 TERM_VCM__P18 TERM_VCM__N14 1185.04
RNR800 TERM_VCM__P18 TERM_VCM__N15 1134.42
RNR801 TERM_VCM__P18 TERM_VCM__N16 1082.29
RNR802 TERM_VCM__P18 TERM_VCM__N17 1032.7
RNR803 TERM_VCM__P18 TERM_VCM__N18 984.04
RNR804 TERM_VCM__P18 TERM_VCM__N19 934.85
RNR805 TERM_VCM__P18 TERM_VCM__N20 889.03
RNR806 TERM_VCM__P18 TERM_VCM__N21 844.969
RNR807 TERM_VCM__P18 TERM_VCM__N22 801.631
RNR808 TERM_VCM__P18 TERM_VCM__N23 762.988
RNR809 TERM_VCM__P18 TERM_VCM__N24 728.611
RNR810 TERM_VCM__P19 TERM_VCM__P20 173.863
RNR811 TERM_VCM__P19 TERM_VCM__P21 183.55
RNR812 TERM_VCM__P19 TERM_VCM__P22 191.7
RNR813 TERM_VCM__P19 TERM_VCM__P23 198.37
RNR814 TERM_VCM__P19 TERM_VCM__P24 203.82
RNR815 TERM_VCM__P19 TERM_VCM__N0 1559.66
RNR816 TERM_VCM__P19 TERM_VCM__N1 1561.1
RNR817 TERM_VCM__P19 TERM_VCM__N2 1554.45
RNR818 TERM_VCM__P19 TERM_VCM__N3 1540.31
RNR819 TERM_VCM__P19 TERM_VCM__N4 1520.61
RNR820 TERM_VCM__P19 TERM_VCM__N5 1494.55
RNR821 TERM_VCM__P19 TERM_VCM__N6 1464.59
RNR822 TERM_VCM__P19 TERM_VCM__N7 1430.43
RNR823 TERM_VCM__P19 TERM_VCM__N8 1391.21
RNR824 TERM_VCM__P19 TERM_VCM__N9 1350.28
RNR825 TERM_VCM__P19 TERM_VCM__N10 1317.43
RNR826 TERM_VCM__P19 TERM_VCM__N11 1270.68
RNR827 TERM_VCM__P19 TERM_VCM__N12 1223.95
RNR828 TERM_VCM__P19 TERM_VCM__N13 1176.16
RNR829 TERM_VCM__P19 TERM_VCM__N14 1126.16
RNR830 TERM_VCM__P19 TERM_VCM__N15 1077.96
RNR831 TERM_VCM__P19 TERM_VCM__N16 1028.34
RNR832 TERM_VCM__P19 TERM_VCM__N17 981.149
RNR833 TERM_VCM__P19 TERM_VCM__N18 934.852
RNR834 TERM_VCM__P19 TERM_VCM__N19 888.064
RNR835 TERM_VCM__P19 TERM_VCM__N20 844.49
RNR836 TERM_VCM__P19 TERM_VCM__N21 802.596
RNR837 TERM_VCM__P19 TERM_VCM__N22 761.396
RNR838 TERM_VCM__P19 TERM_VCM__N23 724.665
RNR839 TERM_VCM__P19 TERM_VCM__N24 691.993
RNR840 TERM_VCM__P20 TERM_VCM__P21 171.349
RNR841 TERM_VCM__P20 TERM_VCM__P22 180.528
RNR842 TERM_VCM__P20 TERM_VCM__P23 187.504
RNR843 TERM_VCM__P20 TERM_VCM__P24 192.867
RNR844 TERM_VCM__P20 TERM_VCM__N0 1487.73
RNR845 TERM_VCM__P20 TERM_VCM__N1 1488.22
RNR846 TERM_VCM__P20 TERM_VCM__N2 1481.31
RNR847 TERM_VCM__P20 TERM_VCM__N3 1467.43
RNR848 TERM_VCM__P20 TERM_VCM__N4 1448.35
RNR849 TERM_VCM__P20 TERM_VCM__N5 1423.25
RNR850 TERM_VCM__P20 TERM_VCM__N6 1394.49
RNR851 TERM_VCM__P20 TERM_VCM__N7 1361.77
RNR852 TERM_VCM__P20 TERM_VCM__N8 1324.24
RNR853 TERM_VCM__P20 TERM_VCM__N9 1285.12
RNR854 TERM_VCM__P20 TERM_VCM__N10 1253.71
RNR855 TERM_VCM__P20 TERM_VCM__N11 1209.08
RNR856 TERM_VCM__P20 TERM_VCM__N12 1164.5
RNR857 TERM_VCM__P20 TERM_VCM__N13 1118.93
RNR858 TERM_VCM__P20 TERM_VCM__N14 1071.27
RNR859 TERM_VCM__P20 TERM_VCM__N15 1025.33
RNR860 TERM_VCM__P20 TERM_VCM__N16 978.059
RNR861 TERM_VCM__P20 TERM_VCM__N17 933.116
RNR862 TERM_VCM__P20 TERM_VCM__N18 889.033
RNR863 TERM_VCM__P20 TERM_VCM__N19 844.491
RNR864 TERM_VCM__P20 TERM_VCM__N20 803.016
RNR865 TERM_VCM__P20 TERM_VCM__N21 763.147
RNR866 TERM_VCM__P20 TERM_VCM__N22 723.943
RNR867 TERM_VCM__P20 TERM_VCM__N23 688.996
RNR868 TERM_VCM__P20 TERM_VCM__N24 657.914
RNR869 TERM_VCM__P21 TERM_VCM__P22 168.315
RNR870 TERM_VCM__P21 TERM_VCM__P23 176.197
RNR871 TERM_VCM__P21 TERM_VCM__P24 181.685
RNR872 TERM_VCM__P21 TERM_VCM__N0 1417.87
RNR873 TERM_VCM__P21 TERM_VCM__N1 1417.58
RNR874 TERM_VCM__P21 TERM_VCM__N2 1410.51
RNR875 TERM_VCM__P21 TERM_VCM__N3 1396.93
RNR876 TERM_VCM__P21 TERM_VCM__N4 1378.5
RNR877 TERM_VCM__P21 TERM_VCM__N5 1354.38
RNR878 TERM_VCM__P21 TERM_VCM__N6 1326.82
RNR879 TERM_VCM__P21 TERM_VCM__N7 1295.52
RNR880 TERM_VCM__P21 TERM_VCM__N8 1259.65
RNR881 TERM_VCM__P21 TERM_VCM__N9 1222.3
RNR882 TERM_VCM__P21 TERM_VCM__N10 1192.3
RNR883 TERM_VCM__P21 TERM_VCM__N11 1149.74
RNR884 TERM_VCM__P21 TERM_VCM__N12 1107.24
RNR885 TERM_VCM__P21 TERM_VCM__N13 1063.83
RNR886 TERM_VCM__P21 TERM_VCM__N14 1018.43
RNR887 TERM_VCM__P21 TERM_VCM__N15 974.693
RNR888 TERM_VCM__P21 TERM_VCM__N16 929.691
RNR889 TERM_VCM__P21 TERM_VCM__N17 886.919
RNR890 TERM_VCM__P21 TERM_VCM__N18 844.973
RNR891 TERM_VCM__P21 TERM_VCM__N19 802.599
RNR892 TERM_VCM__P21 TERM_VCM__N20 763.149
RNR893 TERM_VCM__P21 TERM_VCM__N21 725.231
RNR894 TERM_VCM__P21 TERM_VCM__N22 687.95
RNR895 TERM_VCM__P21 TERM_VCM__N23 654.721
RNR896 TERM_VCM__P21 TERM_VCM__N24 625.17
RNR897 TERM_VCM__P22 TERM_VCM__P23 163.471
RNR898 TERM_VCM__P22 TERM_VCM__P24 169.538
RNR899 TERM_VCM__P22 TERM_VCM__N0 1348.53
RNR900 TERM_VCM__P22 TERM_VCM__N1 1347.6
RNR901 TERM_VCM__P22 TERM_VCM__N2 1340.45
RNR902 TERM_VCM__P22 TERM_VCM__N3 1327.24
RNR903 TERM_VCM__P22 TERM_VCM__N4 1309.49
RNR904 TERM_VCM__P22 TERM_VCM__N5 1286.38
RNR905 TERM_VCM__P22 TERM_VCM__N6 1260.03
RNR906 TERM_VCM__P22 TERM_VCM__N7 1230.15
RNR907 TERM_VCM__P22 TERM_VCM__N8 1195.96
RNR908 TERM_VCM__P22 TERM_VCM__N9 1160.37
RNR909 TERM_VCM__P22 TERM_VCM__N10 1131.78
RNR910 TERM_VCM__P22 TERM_VCM__N11 1091.28
RNR911 TERM_VCM__P22 TERM_VCM__N12 1050.85
RNR912 TERM_VCM__P22 TERM_VCM__N13 1009.57
RNR913 TERM_VCM__P22 TERM_VCM__N14 966.417
RNR914 TERM_VCM__P22 TERM_VCM__N15 924.855
RNR915 TERM_VCM__P22 TERM_VCM__N16 882.1
RNR916 TERM_VCM__P22 TERM_VCM__N17 841.472
RNR917 TERM_VCM__P22 TERM_VCM__N18 801.636
RNR918 TERM_VCM__P22 TERM_VCM__N19 761.4
RNR919 TERM_VCM__P22 TERM_VCM__N20 723.946
RNR920 TERM_VCM__P22 TERM_VCM__N21 687.952
RNR921 TERM_VCM__P22 TERM_VCM__N22 652.566
RNR922 TERM_VCM__P22 TERM_VCM__N23 621.03
RNR923 TERM_VCM__P22 TERM_VCM__N24 592.985
RNR924 TERM_VCM__P23 TERM_VCM__P24 156.266
RNR925 TERM_VCM__P23 TERM_VCM__N0 1286.24
RNR926 TERM_VCM__P23 TERM_VCM__N1 1284.82
RNR927 TERM_VCM__P23 TERM_VCM__N2 1277.66
RNR928 TERM_VCM__P23 TERM_VCM__N3 1264.82
RNR929 TERM_VCM__P23 TERM_VCM__N4 1247.71
RNR930 TERM_VCM__P23 TERM_VCM__N5 1225.53
RNR931 TERM_VCM__P23 TERM_VCM__N6 1200.3
RNR932 TERM_VCM__P23 TERM_VCM__N7 1171.71
RNR933 TERM_VCM__P23 TERM_VCM__N8 1139.03
RNR934 TERM_VCM__P23 TERM_VCM__N9 1105.04
RNR935 TERM_VCM__P23 TERM_VCM__N10 1077.73
RNR936 TERM_VCM__P23 TERM_VCM__N11 1039.08
RNR937 TERM_VCM__P23 TERM_VCM__N12 1000.52
RNR938 TERM_VCM__P23 TERM_VCM__N13 961.15
RNR939 TERM_VCM__P23 TERM_VCM__N14 920.009
RNR940 TERM_VCM__P23 TERM_VCM__N15 880.395
RNR941 TERM_VCM__P23 TERM_VCM__N16 839.652
RNR942 TERM_VCM__P23 TERM_VCM__N17 800.943
RNR943 TERM_VCM__P23 TERM_VCM__N18 762.995
RNR944 TERM_VCM__P23 TERM_VCM__N19 724.671
RNR945 TERM_VCM__P23 TERM_VCM__N20 689.001
RNR946 TERM_VCM__P23 TERM_VCM__N21 654.724
RNR947 TERM_VCM__P23 TERM_VCM__N22 621.031
RNR948 TERM_VCM__P23 TERM_VCM__N23 591.005
RNR949 TERM_VCM__P23 TERM_VCM__N24 564.305
RNR950 TERM_VCM__P24 TERM_VCM__N0 1230.46
RNR951 TERM_VCM__P24 TERM_VCM__N1 1228.68
RNR952 TERM_VCM__P24 TERM_VCM__N2 1221.55
RNR953 TERM_VCM__P24 TERM_VCM__N3 1209.08
RNR954 TERM_VCM__P24 TERM_VCM__N4 1192.58
RNR955 TERM_VCM__P24 TERM_VCM__N5 1171.25
RNR956 TERM_VCM__P24 TERM_VCM__N6 1147.02
RNR957 TERM_VCM__P24 TERM_VCM__N7 1119.61
RNR958 TERM_VCM__P24 TERM_VCM__N8 1088.29
RNR959 TERM_VCM__P24 TERM_VCM__N9 1055.74
RNR960 TERM_VCM__P24 TERM_VCM__N10 1029.58
RNR961 TERM_VCM__P24 TERM_VCM__N11 992.585
RNR962 TERM_VCM__P24 TERM_VCM__N12 955.695
RNR963 TERM_VCM__P24 TERM_VCM__N13 918.043
RNR964 TERM_VCM__P24 TERM_VCM__N14 878.702
RNR965 TERM_VCM__P24 TERM_VCM__N15 840.828
RNR966 TERM_VCM__P24 TERM_VCM__N16 801.882
RNR967 TERM_VCM__P24 TERM_VCM__N17 764.885
RNR968 TERM_VCM__P24 TERM_VCM__N18 728.62
RNR969 TERM_VCM__P24 TERM_VCM__N19 692
RNR970 TERM_VCM__P24 TERM_VCM__N20 657.92
RNR971 TERM_VCM__P24 TERM_VCM__N21 625.174
RNR972 TERM_VCM__P24 TERM_VCM__N22 592.988
RNR973 TERM_VCM__P24 TERM_VCM__N23 564.307
RNR974 TERM_VCM__P24 TERM_VCM__N24 538.805
RNR975 TERM_VCM__N0 TERM_VCM__N1 116.832
RNR976 TERM_VCM__N0 TERM_VCM__N2 125.768
RNR977 TERM_VCM__N0 TERM_VCM__N3 134.582
RNR978 TERM_VCM__N0 TERM_VCM__N4 143.152
RNR979 TERM_VCM__N0 TERM_VCM__N5 152.227
RNR980 TERM_VCM__N0 TERM_VCM__N6 161.298
RNR981 TERM_VCM__N0 TERM_VCM__N7 170.704
RNR982 TERM_VCM__N0 TERM_VCM__N8 180.85
RNR983 TERM_VCM__N0 TERM_VCM__N9 191.023
RNR984 TERM_VCM__N0 TERM_VCM__N10 203.19
RNR985 TERM_VCM__N0 TERM_VCM__N11 214.732
RNR986 TERM_VCM__N0 TERM_VCM__N12 226.21
RNR987 TERM_VCM__N0 TERM_VCM__N13 238
RNR988 TERM_VCM__N0 TERM_VCM__N14 250.563
RNR989 TERM_VCM__N0 TERM_VCM__N15 262.956
RNR990 TERM_VCM__N0 TERM_VCM__N16 276.038
RNR991 TERM_VCM__N0 TERM_VCM__N17 288.794
RNR992 TERM_VCM__N0 TERM_VCM__N18 301.598
RNR993 TERM_VCM__N0 TERM_VCM__N19 314.833
RNR994 TERM_VCM__N0 TERM_VCM__N20 327.434
RNR995 TERM_VCM__N0 TERM_VCM__N21 339.695
RNR996 TERM_VCM__N0 TERM_VCM__N22 351.886
RNR997 TERM_VCM__N0 TERM_VCM__N23 362.813
RNR998 TERM_VCM__N0 TERM_VCM__N24 372.393
RNR999 TERM_VCM__N1 TERM_VCM__N2 124.249
RNR1000 TERM_VCM__N1 TERM_VCM__N3 133.378
RNR1001 TERM_VCM__N1 TERM_VCM__N4 142.066
RNR1002 TERM_VCM__N1 TERM_VCM__N5 151.176
RNR1003 TERM_VCM__N1 TERM_VCM__N6 160.245
RNR1004 TERM_VCM__N1 TERM_VCM__N7 169.624
RNR1005 TERM_VCM__N1 TERM_VCM__N8 179.728
RNR1006 TERM_VCM__N1 TERM_VCM__N9 189.852
RNR1007 TERM_VCM__N1 TERM_VCM__N10 201.956
RNR1008 TERM_VCM__N1 TERM_VCM__N11 213.434
RNR1009 TERM_VCM__N1 TERM_VCM__N12 224.847
RNR1010 TERM_VCM__N1 TERM_VCM__N13 236.571
RNR1011 TERM_VCM__N1 TERM_VCM__N14 249.063
RNR1012 TERM_VCM__N1 TERM_VCM__N15 261.387
RNR1013 TERM_VCM__N1 TERM_VCM__N16 274.397
RNR1014 TERM_VCM__N1 TERM_VCM__N17 287.083
RNR1015 TERM_VCM__N1 TERM_VCM__N18 299.817
RNR1016 TERM_VCM__N1 TERM_VCM__N19 312.982
RNR1017 TERM_VCM__N1 TERM_VCM__N20 325.518
RNR1018 TERM_VCM__N1 TERM_VCM__N21 337.716
RNR1019 TERM_VCM__N1 TERM_VCM__N22 349.846
RNR1020 TERM_VCM__N1 TERM_VCM__N23 360.721
RNR1021 TERM_VCM__N1 TERM_VCM__N24 370.257
RNR1022 TERM_VCM__N2 TERM_VCM__N3 130.982
RNR1023 TERM_VCM__N2 TERM_VCM__N4 140.167
RNR1024 TERM_VCM__N2 TERM_VCM__N5 149.474
RNR1025 TERM_VCM__N2 TERM_VCM__N6 158.619
RNR1026 TERM_VCM__N2 TERM_VCM__N7 168.006
RNR1027 TERM_VCM__N2 TERM_VCM__N8 178.073
RNR1028 TERM_VCM__N2 TERM_VCM__N9 188.141
RNR1029 TERM_VCM__N2 TERM_VCM__N10 200.163
RNR1030 TERM_VCM__N2 TERM_VCM__N11 211.551
RNR1031 TERM_VCM__N2 TERM_VCM__N12 222.873
RNR1032 TERM_VCM__N2 TERM_VCM__N13 234.499
RNR1033 TERM_VCM__N2 TERM_VCM__N14 246.887
RNR1034 TERM_VCM__N2 TERM_VCM__N15 259.107
RNR1035 TERM_VCM__N2 TERM_VCM__N16 272.007
RNR1036 TERM_VCM__N2 TERM_VCM__N17 284.587
RNR1037 TERM_VCM__N2 TERM_VCM__N18 297.215
RNR1038 TERM_VCM__N2 TERM_VCM__N19 310.271
RNR1039 TERM_VCM__N2 TERM_VCM__N20 322.704
RNR1040 TERM_VCM__N2 TERM_VCM__N21 334.803
RNR1041 TERM_VCM__N2 TERM_VCM__N22 346.836
RNR1042 TERM_VCM__N2 TERM_VCM__N23 357.624
RNR1043 TERM_VCM__N2 TERM_VCM__N24 367.085
RNR1044 TERM_VCM__N3 TERM_VCM__N4 136.968
RNR1045 TERM_VCM__N3 TERM_VCM__N5 146.842
RNR1046 TERM_VCM__N3 TERM_VCM__N6 156.213
RNR1047 TERM_VCM__N3 TERM_VCM__N7 165.668
RNR1048 TERM_VCM__N3 TERM_VCM__N8 175.716
RNR1049 TERM_VCM__N3 TERM_VCM__N9 185.724
RNR1050 TERM_VCM__N3 TERM_VCM__N10 197.645
RNR1051 TERM_VCM__N3 TERM_VCM__N11 208.912
RNR1052 TERM_VCM__N3 TERM_VCM__N12 220.106
RNR1053 TERM_VCM__N3 TERM_VCM__N13 231.598
RNR1054 TERM_VCM__N3 TERM_VCM__N14 243.838
RNR1055 TERM_VCM__N3 TERM_VCM__N15 255.912
RNR1056 TERM_VCM__N3 TERM_VCM__N16 268.657
RNR1057 TERM_VCM__N3 TERM_VCM__N17 281.086
RNR1058 TERM_VCM__N3 TERM_VCM__N18 293.562
RNR1059 TERM_VCM__N3 TERM_VCM__N19 306.462
RNR1060 TERM_VCM__N3 TERM_VCM__N20 318.746
RNR1061 TERM_VCM__N3 TERM_VCM__N21 330.701
RNR1062 TERM_VCM__N3 TERM_VCM__N22 342.591
RNR1063 TERM_VCM__N3 TERM_VCM__N23 353.252
RNR1064 TERM_VCM__N3 TERM_VCM__N24 362.602
RNR1065 TERM_VCM__N4 TERM_VCM__N5 142.973
RNR1066 TERM_VCM__N4 TERM_VCM__N6 152.952
RNR1067 TERM_VCM__N4 TERM_VCM__N7 162.634
RNR1068 TERM_VCM__N4 TERM_VCM__N8 172.733
RNR1069 TERM_VCM__N4 TERM_VCM__N9 182.708
RNR1070 TERM_VCM__N4 TERM_VCM__N10 194.532
RNR1071 TERM_VCM__N4 TERM_VCM__N11 205.664
RNR1072 TERM_VCM__N4 TERM_VCM__N12 216.71
RNR1073 TERM_VCM__N4 TERM_VCM__N13 228.04
RNR1074 TERM_VCM__N4 TERM_VCM__N14 240.102
RNR1075 TERM_VCM__N4 TERM_VCM__N15 251.998
RNR1076 TERM_VCM__N4 TERM_VCM__N16 264.553
RNR1077 TERM_VCM__N4 TERM_VCM__N17 276.795
RNR1078 TERM_VCM__N4 TERM_VCM__N18 289.084
RNR1079 TERM_VCM__N4 TERM_VCM__N19 301.79
RNR1080 TERM_VCM__N4 TERM_VCM__N20 313.891
RNR1081 TERM_VCM__N4 TERM_VCM__N21 325.667
RNR1082 TERM_VCM__N4 TERM_VCM__N22 337.38
RNR1083 TERM_VCM__N4 TERM_VCM__N23 347.882
RNR1084 TERM_VCM__N4 TERM_VCM__N24 357.094
RNR1085 TERM_VCM__N5 TERM_VCM__N6 148.256
RNR1086 TERM_VCM__N5 TERM_VCM__N7 158.564
RNR1087 TERM_VCM__N5 TERM_VCM__N8 168.866
RNR1088 TERM_VCM__N5 TERM_VCM__N9 178.87
RNR1089 TERM_VCM__N5 TERM_VCM__N10 190.614
RNR1090 TERM_VCM__N5 TERM_VCM__N11 201.599
RNR1091 TERM_VCM__N5 TERM_VCM__N12 212.473
RNR1092 TERM_VCM__N5 TERM_VCM__N13 223.608
RNR1093 TERM_VCM__N5 TERM_VCM__N14 235.451
RNR1094 TERM_VCM__N5 TERM_VCM__N15 247.127
RNR1095 TERM_VCM__N5 TERM_VCM__N16 259.446
RNR1096 TERM_VCM__N5 TERM_VCM__N17 271.457
RNR1097 TERM_VCM__N5 TERM_VCM__N18 283.513
RNR1098 TERM_VCM__N5 TERM_VCM__N19 295.977
RNR1099 TERM_VCM__N5 TERM_VCM__N20 307.848
RNR1100 TERM_VCM__N5 TERM_VCM__N21 319.4
RNR1101 TERM_VCM__N5 TERM_VCM__N22 330.891
RNR1102 TERM_VCM__N5 TERM_VCM__N23 341.195
RNR1103 TERM_VCM__N5 TERM_VCM__N24 350.233
RNR1104 TERM_VCM__N6 TERM_VCM__N7 153.22
RNR1105 TERM_VCM__N6 TERM_VCM__N8 164.165
RNR1106 TERM_VCM__N6 TERM_VCM__N9 174.382
RNR1107 TERM_VCM__N6 TERM_VCM__N10 186.136
RNR1108 TERM_VCM__N6 TERM_VCM__N11 197.008
RNR1109 TERM_VCM__N6 TERM_VCM__N12 207.719
RNR1110 TERM_VCM__N6 TERM_VCM__N13 218.654
RNR1111 TERM_VCM__N6 TERM_VCM__N14 230.264
RNR1112 TERM_VCM__N6 TERM_VCM__N15 241.699
RNR1113 TERM_VCM__N6 TERM_VCM__N16 253.758
RNR1114 TERM_VCM__N6 TERM_VCM__N17 265.513
RNR1115 TERM_VCM__N6 TERM_VCM__N18 277.309
RNR1116 TERM_VCM__N6 TERM_VCM__N19 289.505
RNR1117 TERM_VCM__N6 TERM_VCM__N20 301.119
RNR1118 TERM_VCM__N6 TERM_VCM__N21 312.422
RNR1119 TERM_VCM__N6 TERM_VCM__N22 323.665
RNR1120 TERM_VCM__N6 TERM_VCM__N23 333.747
RNR1121 TERM_VCM__N6 TERM_VCM__N24 342.59
RNR1122 TERM_VCM__N7 TERM_VCM__N8 158.081
RNR1123 TERM_VCM__N7 TERM_VCM__N9 168.96
RNR1124 TERM_VCM__N7 TERM_VCM__N10 180.915
RNR1125 TERM_VCM__N7 TERM_VCM__N11 191.759
RNR1126 TERM_VCM__N7 TERM_VCM__N12 202.342
RNR1127 TERM_VCM__N7 TERM_VCM__N13 213.084
RNR1128 TERM_VCM__N7 TERM_VCM__N14 224.448
RNR1129 TERM_VCM__N7 TERM_VCM__N15 235.625
RNR1130 TERM_VCM__N7 TERM_VCM__N16 247.399
RNR1131 TERM_VCM__N7 TERM_VCM__N17 258.87
RNR1132 TERM_VCM__N7 TERM_VCM__N18 270.379
RNR1133 TERM_VCM__N7 TERM_VCM__N19 282.275
RNR1134 TERM_VCM__N7 TERM_VCM__N20 293.603
RNR1135 TERM_VCM__N7 TERM_VCM__N21 304.627
RNR1136 TERM_VCM__N7 TERM_VCM__N22 315.593
RNR1137 TERM_VCM__N7 TERM_VCM__N23 325.426
RNR1138 TERM_VCM__N7 TERM_VCM__N24 334.051
RNR1139 TERM_VCM__N8 TERM_VCM__N9 161.987
RNR1140 TERM_VCM__N8 TERM_VCM__N10 174.616
RNR1141 TERM_VCM__N8 TERM_VCM__N11 185.602
RNR1142 TERM_VCM__N8 TERM_VCM__N12 196.137
RNR1143 TERM_VCM__N8 TERM_VCM__N13 206.713
RNR1144 TERM_VCM__N8 TERM_VCM__N14 217.827
RNR1145 TERM_VCM__N8 TERM_VCM__N15 228.728
RNR1146 TERM_VCM__N8 TERM_VCM__N16 240.187
RNR1147 TERM_VCM__N8 TERM_VCM__N17 251.343
RNR1148 TERM_VCM__N8 TERM_VCM__N18 262.529
RNR1149 TERM_VCM__N8 TERM_VCM__N19 274.086
RNR1150 TERM_VCM__N8 TERM_VCM__N20 285.091
RNR1151 TERM_VCM__N8 TERM_VCM__N21 295.799
RNR1152 TERM_VCM__N8 TERM_VCM__N22 306.45
RNR1153 TERM_VCM__N8 TERM_VCM__N23 316.001
RNR1154 TERM_VCM__N8 TERM_VCM__N24 324.379
RNR1155 TERM_VCM__N9 TERM_VCM__N10 167.26
RNR1156 TERM_VCM__N9 TERM_VCM__N11 178.772
RNR1157 TERM_VCM__N9 TERM_VCM__N12 189.471
RNR1158 TERM_VCM__N9 TERM_VCM__N13 199.991
RNR1159 TERM_VCM__N9 TERM_VCM__N14 210.911
RNR1160 TERM_VCM__N9 TERM_VCM__N15 221.561
RNR1161 TERM_VCM__N9 TERM_VCM__N16 232.715
RNR1162 TERM_VCM__N9 TERM_VCM__N17 243.557
RNR1163 TERM_VCM__N9 TERM_VCM__N18 254.415
RNR1164 TERM_VCM__N9 TERM_VCM__N19 265.627
RNR1165 TERM_VCM__N9 TERM_VCM__N20 276.3
RNR1166 TERM_VCM__N9 TERM_VCM__N21 286.683
RNR1167 TERM_VCM__N9 TERM_VCM__N22 297.009
RNR1168 TERM_VCM__N9 TERM_VCM__N23 306.269
RNR1169 TERM_VCM__N9 TERM_VCM__N24 314.391
RNR1170 TERM_VCM__N10 TERM_VCM__N11 170.796
RNR1171 TERM_VCM__N10 TERM_VCM__N12 182.938
RNR1172 TERM_VCM__N10 TERM_VCM__N13 194.035
RNR1173 TERM_VCM__N10 TERM_VCM__N14 205.094
RNR1174 TERM_VCM__N10 TERM_VCM__N15 215.673
RNR1175 TERM_VCM__N10 TERM_VCM__N16 226.642
RNR1176 TERM_VCM__N10 TERM_VCM__N17 237.257
RNR1177 TERM_VCM__N10 TERM_VCM__N18 247.864
RNR1178 TERM_VCM__N10 TERM_VCM__N19 258.804
RNR1179 TERM_VCM__N10 TERM_VCM__N20 269.211
RNR1180 TERM_VCM__N10 TERM_VCM__N21 279.334
RNR1181 TERM_VCM__N10 TERM_VCM__N22 289.399
RNR1182 TERM_VCM__N10 TERM_VCM__N23 298.424
RNR1183 TERM_VCM__N10 TERM_VCM__N24 306.34
RNR1184 TERM_VCM__N11 TERM_VCM__N12 173.168
RNR1185 TERM_VCM__N11 TERM_VCM__N13 185.344
RNR1186 TERM_VCM__N11 TERM_VCM__N14 196.758
RNR1187 TERM_VCM__N11 TERM_VCM__N15 207.33
RNR1188 TERM_VCM__N11 TERM_VCM__N16 218.093
RNR1189 TERM_VCM__N11 TERM_VCM__N17 228.422
RNR1190 TERM_VCM__N11 TERM_VCM__N18 238.694
RNR1191 TERM_VCM__N11 TERM_VCM__N19 249.261
RNR1192 TERM_VCM__N11 TERM_VCM__N20 259.303
RNR1193 TERM_VCM__N11 TERM_VCM__N21 269.064
RNR1194 TERM_VCM__N11 TERM_VCM__N22 278.766
RNR1195 TERM_VCM__N11 TERM_VCM__N23 287.464
RNR1196 TERM_VCM__N11 TERM_VCM__N24 295.09
RNR1197 TERM_VCM__N12 TERM_VCM__N13 175.218
RNR1198 TERM_VCM__N12 TERM_VCM__N14 187.722
RNR1199 TERM_VCM__N12 TERM_VCM__N15 198.657
RNR1200 TERM_VCM__N12 TERM_VCM__N16 209.402
RNR1201 TERM_VCM__N12 TERM_VCM__N17 219.541
RNR1202 TERM_VCM__N12 TERM_VCM__N18 229.528
RNR1203 TERM_VCM__N12 TERM_VCM__N19 239.751
RNR1204 TERM_VCM__N12 TERM_VCM__N20 249.444
RNR1205 TERM_VCM__N12 TERM_VCM__N21 258.852
RNR1206 TERM_VCM__N12 TERM_VCM__N22 268.196
RNR1207 TERM_VCM__N12 TERM_VCM__N23 276.57
RNR1208 TERM_VCM__N12 TERM_VCM__N24 283.909
RNR1209 TERM_VCM__N13 TERM_VCM__N14 177.098
RNR1210 TERM_VCM__N13 TERM_VCM__N15 189.104
RNR1211 TERM_VCM__N13 TERM_VCM__N16 200.192
RNR1212 TERM_VCM__N13 TERM_VCM__N17 210.317
RNR1213 TERM_VCM__N13 TERM_VCM__N18 220.106
RNR1214 TERM_VCM__N13 TERM_VCM__N19 230.024
RNR1215 TERM_VCM__N13 TERM_VCM__N20 239.384
RNR1216 TERM_VCM__N13 TERM_VCM__N21 248.446
RNR1217 TERM_VCM__N13 TERM_VCM__N22 257.432
RNR1218 TERM_VCM__N13 TERM_VCM__N23 265.478
RNR1219 TERM_VCM__N13 TERM_VCM__N24 272.525
RNR1220 TERM_VCM__N14 TERM_VCM__N15 177.695
RNR1221 TERM_VCM__N14 TERM_VCM__N16 189.875
RNR1222 TERM_VCM__N14 TERM_VCM__N17 200.347
RNR1223 TERM_VCM__N14 TERM_VCM__N18 210.106
RNR1224 TERM_VCM__N14 TERM_VCM__N19 219.796
RNR1225 TERM_VCM__N14 TERM_VCM__N20 228.853
RNR1226 TERM_VCM__N14 TERM_VCM__N21 237.576
RNR1227 TERM_VCM__N14 TERM_VCM__N22 246.199
RNR1228 TERM_VCM__N14 TERM_VCM__N23 253.909
RNR1229 TERM_VCM__N14 TERM_VCM__N24 260.653
RNR1230 TERM_VCM__N15 TERM_VCM__N16 178.426
RNR1231 TERM_VCM__N15 TERM_VCM__N17 189.988
RNR1232 TERM_VCM__N15 TERM_VCM__N18 200.102
RNR1233 TERM_VCM__N15 TERM_VCM__N19 209.767
RNR1234 TERM_VCM__N15 TERM_VCM__N20 218.631
RNR1235 TERM_VCM__N15 TERM_VCM__N21 227.077
RNR1236 TERM_VCM__N15 TERM_VCM__N22 235.375
RNR1237 TERM_VCM__N15 TERM_VCM__N23 242.773
RNR1238 TERM_VCM__N15 TERM_VCM__N24 249.227
RNR1239 TERM_VCM__N16 TERM_VCM__N17 177.89
RNR1240 TERM_VCM__N16 TERM_VCM__N18 189.103
RNR1241 TERM_VCM__N16 TERM_VCM__N19 199.115
RNR1242 TERM_VCM__N16 TERM_VCM__N20 207.957
RNR1243 TERM_VCM__N16 TERM_VCM__N21 216.207
RNR1244 TERM_VCM__N16 TERM_VCM__N22 224.214
RNR1245 TERM_VCM__N16 TERM_VCM__N23 231.309
RNR1246 TERM_VCM__N16 TERM_VCM__N24 237.47
RNR1247 TERM_VCM__N17 TERM_VCM__N18 177.137
RNR1248 TERM_VCM__N17 TERM_VCM__N19 188.244
RNR1249 TERM_VCM__N17 TERM_VCM__N20 197.443
RNR1250 TERM_VCM__N17 TERM_VCM__N21 205.693
RNR1251 TERM_VCM__N17 TERM_VCM__N22 213.514
RNR1252 TERM_VCM__N17 TERM_VCM__N23 220.362
RNR1253 TERM_VCM__N17 TERM_VCM__N24 226.254
RNR1254 TERM_VCM__N18 TERM_VCM__N19 176.134
RNR1255 TERM_VCM__N18 TERM_VCM__N20 186.403
RNR1256 TERM_VCM__N18 TERM_VCM__N21 195.017
RNR1257 TERM_VCM__N18 TERM_VCM__N22 202.83
RNR1258 TERM_VCM__N18 TERM_VCM__N23 209.514
RNR1259 TERM_VCM__N18 TERM_VCM__N24 215.163
RNR1260 TERM_VCM__N19 TERM_VCM__N20 173.846
RNR1261 TERM_VCM__N19 TERM_VCM__N21 183.532
RNR1262 TERM_VCM__N19 TERM_VCM__N22 191.682
RNR1263 TERM_VCM__N19 TERM_VCM__N23 198.352
RNR1264 TERM_VCM__N19 TERM_VCM__N24 203.801
RNR1265 TERM_VCM__N20 TERM_VCM__N21 171.332
RNR1266 TERM_VCM__N20 TERM_VCM__N22 180.511
RNR1267 TERM_VCM__N20 TERM_VCM__N23 187.486
RNR1268 TERM_VCM__N20 TERM_VCM__N24 192.85
RNR1269 TERM_VCM__N21 TERM_VCM__N22 168.299
RNR1270 TERM_VCM__N21 TERM_VCM__N23 176.18
RNR1271 TERM_VCM__N21 TERM_VCM__N24 181.668
RNR1272 TERM_VCM__N22 TERM_VCM__N23 163.455
RNR1273 TERM_VCM__N22 TERM_VCM__N24 169.523
RNR1274 TERM_VCM__N23 TERM_VCM__N24 156.252
RNR1275 PAD_P PAD_P__feed 10.1399
RNR1276 PAD_P PAD_P__dio 160.659
RNR1277 PAD_P PAD_P__dio 154.036
RNR1278 PAD_P PAD_P__dio 143.121
RNR1279 PAD_P PAD_P__dio 129.272
RNR1280 PAD_P PAD_P__dio 217.368
RNR1281 PAD_P PAD_P__dio 194.762
RNR1282 PAD_P PAD_P__dio 173.916
RNR1283 PAD_P PAD_P__dio 149.518
RNR1284 PAD_P PAD_P__dio 325.8
RNR1285 PAD_P PAD_P__dio 291.907
RNR1286 PAD_P PAD_P__dio 260.621
RNR1287 PAD_P PAD_P__dio 223.904
RNR1288 PAD_P__feed PAD_P__mim 1.90692
RNR1289 PAD_P__feed PAD_P__h10 1.20595e+06
RNR1290 PAD_P__feed PAD_P__h11 2.5569e+06
RNR1291 PAD_P__feed PAD_P__h12 4.97266e+06
RNR1292 PAD_P__feed PAD_P__h13 7.72309e+06
RNR1293 PAD_P__feed PAD_P__h14 9.62006e+06
RNR1294 PAD_P__feed PAD_P__h15 1.10183e+07
RNR1295 PAD_P__feed PAD_P__h16 1.20532e+07
RNR1296 PAD_P__feed PAD_P__h17 1.29597e+07
RNR1297 PAD_P__feed PAD_P__h18 1.38845e+07
RNR1298 PAD_P__feed PAD_P__h19 1.46849e+07
RNR1299 PAD_P__feed PAD_P__h20 1.5462e+07
RNR1300 PAD_P__feed PAD_P__h21 1.64222e+07
RNR1301 PAD_P__feed PAD_P__h22 1.74918e+07
RNR1302 PAD_P__feed PAD_P__h23 1.83423e+07
RNR1303 PAD_P__feed PAD_P__h24 1.87594e+07
RNR1304 PAD_P__feed PAD_P__h0 375.748
RNR1305 PAD_P__feed PAD_P__h1 758.873
RNR1306 PAD_P__feed PAD_P__h2 1744.94
RNR1307 PAD_P__feed PAD_P__h3 3806.72
RNR1308 PAD_P__feed PAD_P__h4 9059.48
RNR1309 PAD_P__feed PAD_P__h5 20000.1
RNR1310 PAD_P__feed PAD_P__h6 43871.5
RNR1311 PAD_P__feed PAD_P__h7 103409
RNR1312 PAD_P__feed PAD_P__h8 228901
RNR1313 PAD_P__feed PAD_P__h9 556691
RNR1314 PAD_P__feed PAD_P__dio 15.469
RNR1315 PAD_P__feed PAD_P__dio 14.8307
RNR1316 PAD_P__feed PAD_P__dio 13.7779
RNR1317 PAD_P__feed PAD_P__dio 12.4406
RNR1318 PAD_P__feed PAD_P__dio 19.5565
RNR1319 PAD_P__feed PAD_P__dio 17.5206
RNR1320 PAD_P__feed PAD_P__dio 15.6367
RNR1321 PAD_P__feed PAD_P__dio 13.4116
RNR1322 PAD_P__feed PAD_P__dio 38.3876
RNR1323 PAD_P__feed PAD_P__dio 34.3936
RNR1324 PAD_P__feed PAD_P__dio 30.7052
RNR1325 PAD_P__feed PAD_P__dio 26.3714
RNR1326 PAD_P__mim PAD_P__h10 14.4041
RNR1327 PAD_P__mim PAD_P__h11 14.6831
RNR1328 PAD_P__mim PAD_P__h12 15.2332
RNR1329 PAD_P__mim PAD_P__h13 16.3381
RNR1330 PAD_P__mim PAD_P__h14 17.6148
RNR1331 PAD_P__mim PAD_P__h15 19.1127
RNR1332 PAD_P__mim PAD_P__h16 20.5551
RNR1333 PAD_P__mim PAD_P__h17 21.9766
RNR1334 PAD_P__mim PAD_P__h18 23.4973
RNR1335 PAD_P__mim PAD_P__h19 24.8373
RNR1336 PAD_P__mim PAD_P__h20 26.1467
RNR1337 PAD_P__mim PAD_P__h21 27.7689
RNR1338 PAD_P__mim PAD_P__h22 29.5777
RNR1339 PAD_P__mim PAD_P__h23 31.0158
RNR1340 PAD_P__mim PAD_P__h24 31.7211
RNR1341 PAD_P__mim PAD_P__h0 14.4835
RNR1342 PAD_P__mim PAD_P__h1 14.2311
RNR1343 PAD_P__mim PAD_P__h2 14.0937
RNR1344 PAD_P__mim PAD_P__h3 14.0393
RNR1345 PAD_P__mim PAD_P__h4 14.0108
RNR1346 PAD_P__mim PAD_P__h5 14.0122
RNR1347 PAD_P__mim PAD_P__h6 14.0075
RNR1348 PAD_P__mim PAD_P__h7 14.0126
RNR1349 PAD_P__mim PAD_P__h8 14.0276
RNR1350 PAD_P__mim PAD_P__h9 13.2648
RNR1351 PAD_P__h10 PAD_P__h11 2096.34
RNR1352 PAD_P__h10 PAD_P__h12 4088.54
RNR1353 PAD_P__h10 PAD_P__h13 6362.24
RNR1354 PAD_P__h10 PAD_P__h14 7932.65
RNR1355 PAD_P__h10 PAD_P__h15 9089.24
RNR1356 PAD_P__h10 PAD_P__h16 9944.29
RNR1357 PAD_P__h10 PAD_P__h17 10692.7
RNR1358 PAD_P__h10 PAD_P__h18 11455.9
RNR1359 PAD_P__h10 PAD_P__h19 12116.3
RNR1360 PAD_P__h10 PAD_P__h20 12757.5
RNR1361 PAD_P__h10 PAD_P__h21 13549.7
RNR1362 PAD_P__h10 PAD_P__h22 14432.3
RNR1363 PAD_P__h10 PAD_P__h23 15134
RNR1364 PAD_P__h10 PAD_P__h24 15478.1
RNR1365 PAD_P__h10 PAD_P__h0 2.67343e+06
RNR1366 PAD_P__h10 PAD_P__h1 1.48809e+06
RNR1367 PAD_P__h10 PAD_P__h2 664873
RNR1368 PAD_P__h10 PAD_P__h3 303725
RNR1369 PAD_P__h10 PAD_P__h4 128946
RNR1370 PAD_P__h10 PAD_P__h5 57526.4
RNR1371 PAD_P__h10 PAD_P__h6 26305.6
RNR1372 PAD_P__h10 PAD_P__h7 11149.3
RNR1373 PAD_P__h10 PAD_P__h8 5077.61
RNR1374 PAD_P__h10 PAD_P__h9 2485.81
RNR1375 PAD_P__h11 PAD_P__h12 1822.77
RNR1376 PAD_P__h11 PAD_P__h13 2851.93
RNR1377 PAD_P__h11 PAD_P__h14 3565.67
RNR1378 PAD_P__h11 PAD_P__h15 4090.21
RNR1379 PAD_P__h11 PAD_P__h16 4476.66
RNR1380 PAD_P__h11 PAD_P__h17 4814.16
RNR1381 PAD_P__h11 PAD_P__h18 5158.02
RNR1382 PAD_P__h11 PAD_P__h19 5455.43
RNR1383 PAD_P__h11 PAD_P__h20 5744.17
RNR1384 PAD_P__h11 PAD_P__h21 6100.88
RNR1385 PAD_P__h11 PAD_P__h22 6498.27
RNR1386 PAD_P__h11 PAD_P__h23 6814.22
RNR1387 PAD_P__h11 PAD_P__h24 6969.17
RNR1388 PAD_P__h11 PAD_P__h0 5.66833e+06
RNR1389 PAD_P__h11 PAD_P__h1 3.15512e+06
RNR1390 PAD_P__h11 PAD_P__h2 1.4097e+06
RNR1391 PAD_P__h11 PAD_P__h3 643972
RNR1392 PAD_P__h11 PAD_P__h4 273397
RNR1393 PAD_P__h11 PAD_P__h5 121972
RNR1394 PAD_P__h11 PAD_P__h6 55776.5
RNR1395 PAD_P__h11 PAD_P__h7 23643.2
RNR1396 PAD_P__h11 PAD_P__h8 10771.3
RNR1397 PAD_P__h11 PAD_P__h9 5278.32
RNR1398 PAD_P__h12 PAD_P__h13 1331.96
RNR1399 PAD_P__h12 PAD_P__h14 1682.05
RNR1400 PAD_P__h12 PAD_P__h15 1937.58
RNR1401 PAD_P__h12 PAD_P__h16 2123.56
RNR1402 PAD_P__h12 PAD_P__h17 2284.7
RNR1403 PAD_P__h12 PAD_P__h18 2448.3
RNR1404 PAD_P__h12 PAD_P__h19 2589.59
RNR1405 PAD_P__h12 PAD_P__h20 2726.7
RNR1406 PAD_P__h12 PAD_P__h21 2896.03
RNR1407 PAD_P__h12 PAD_P__h22 3084.67
RNR1408 PAD_P__h12 PAD_P__h23 3234.65
RNR1409 PAD_P__h12 PAD_P__h24 3308.2
RNR1410 PAD_P__h12 PAD_P__h0 1.10237e+07
RNR1411 PAD_P__h12 PAD_P__h1 6.13606e+06
RNR1412 PAD_P__h12 PAD_P__h2 2.74157e+06
RNR1413 PAD_P__h12 PAD_P__h3 1.25239e+06
RNR1414 PAD_P__h12 PAD_P__h4 531703
RNR1415 PAD_P__h12 PAD_P__h5 237211
RNR1416 PAD_P__h12 PAD_P__h6 108476
RNR1417 PAD_P__h12 PAD_P__h7 45984.1
RNR1418 PAD_P__h12 PAD_P__h8 20952.3
RNR1419 PAD_P__h12 PAD_P__h9 10271.2
RNR1420 PAD_P__h13 PAD_P__h14 826.293
RNR1421 PAD_P__h13 PAD_P__h15 972.983
RNR1422 PAD_P__h13 PAD_P__h16 1074.22
RNR1423 PAD_P__h13 PAD_P__h17 1158.6
RNR1424 PAD_P__h13 PAD_P__h18 1242.67
RNR1425 PAD_P__h13 PAD_P__h19 1314.72
RNR1426 PAD_P__h13 PAD_P__h20 1384.45
RNR1427 PAD_P__h13 PAD_P__h21 1470.46
RNR1428 PAD_P__h13 PAD_P__h22 1566.24
RNR1429 PAD_P__h13 PAD_P__h23 1642.39
RNR1430 PAD_P__h13 PAD_P__h24 1679.74
RNR1431 PAD_P__h13 PAD_P__h0 1.71211e+07
RNR1432 PAD_P__h13 PAD_P__h1 9.52999e+06
RNR1433 PAD_P__h13 PAD_P__h2 4.25797e+06
RNR1434 PAD_P__h13 PAD_P__h3 1.94511e+06
RNR1435 PAD_P__h13 PAD_P__h4 825794
RNR1436 PAD_P__h13 PAD_P__h5 368416
RNR1437 PAD_P__h13 PAD_P__h6 168477
RNR1438 PAD_P__h13 PAD_P__h7 71421.5
RNR1439 PAD_P__h13 PAD_P__h8 32545.7
RNR1440 PAD_P__h13 PAD_P__h9 15958.6
RNR1441 PAD_P__h14 PAD_P__h15 608.059
RNR1442 PAD_P__h14 PAD_P__h16 685.722
RNR1443 PAD_P__h14 PAD_P__h17 745.013
RNR1444 PAD_P__h14 PAD_P__h18 801.2
RNR1445 PAD_P__h14 PAD_P__h19 848.298
RNR1446 PAD_P__h14 PAD_P__h20 893.513
RNR1447 PAD_P__h14 PAD_P__h21 949.09
RNR1448 PAD_P__h14 PAD_P__h22 1010.91
RNR1449 PAD_P__h14 PAD_P__h23 1060.06
RNR1450 PAD_P__h14 PAD_P__h24 1084.17
RNR1451 PAD_P__h14 PAD_P__h0 2.13264e+07
RNR1452 PAD_P__h14 PAD_P__h1 1.18708e+07
RNR1453 PAD_P__h14 PAD_P__h2 5.30383e+06
RNR1454 PAD_P__h14 PAD_P__h3 2.42287e+06
RNR1455 PAD_P__h14 PAD_P__h4 1.02863e+06
RNR1456 PAD_P__h14 PAD_P__h5 458909
RNR1457 PAD_P__h14 PAD_P__h6 209860
RNR1458 PAD_P__h14 PAD_P__h7 88966.3
RNR1459 PAD_P__h14 PAD_P__h8 40542.5
RNR1460 PAD_P__h14 PAD_P__h9 19882.3
RNR1461 PAD_P__h15 PAD_P__h16 470.865
RNR1462 PAD_P__h15 PAD_P__h17 522.986
RNR1463 PAD_P__h15 PAD_P__h18 567.045
RNR1464 PAD_P__h15 PAD_P__h19 601.797
RNR1465 PAD_P__h15 PAD_P__h20 634.372
RNR1466 PAD_P__h15 PAD_P__h21 673.973
RNR1467 PAD_P__h15 PAD_P__h22 717.876
RNR1468 PAD_P__h15 PAD_P__h23 752.779
RNR1469 PAD_P__h15 PAD_P__h24 769.897
RNR1470 PAD_P__h15 PAD_P__h0 2.44261e+07
RNR1471 PAD_P__h15 PAD_P__h1 1.35961e+07
RNR1472 PAD_P__h15 PAD_P__h2 6.07469e+06
RNR1473 PAD_P__h15 PAD_P__h3 2.77502e+06
RNR1474 PAD_P__h15 PAD_P__h4 1.17813e+06
RNR1475 PAD_P__h15 PAD_P__h5 525607
RNR1476 PAD_P__h15 PAD_P__h6 240361
RNR1477 PAD_P__h15 PAD_P__h7 101898
RNR1478 PAD_P__h15 PAD_P__h8 46436.3
RNR1479 PAD_P__h15 PAD_P__h9 22773.9
RNR1480 PAD_P__h16 PAD_P__h17 395.836
RNR1481 PAD_P__h16 PAD_P__h18 437.748
RNR1482 PAD_P__h16 PAD_P__h19 467.279
RNR1483 PAD_P__h16 PAD_P__h20 493.532
RNR1484 PAD_P__h16 PAD_P__h21 524.618
RNR1485 PAD_P__h16 PAD_P__h22 558.794
RNR1486 PAD_P__h16 PAD_P__h23 585.963
RNR1487 PAD_P__h16 PAD_P__h24 599.287
RNR1488 PAD_P__h16 PAD_P__h0 2.67204e+07
RNR1489 PAD_P__h16 PAD_P__h1 1.48732e+07
RNR1490 PAD_P__h16 PAD_P__h2 6.64528e+06
RNR1491 PAD_P__h16 PAD_P__h3 3.03567e+06
RNR1492 PAD_P__h16 PAD_P__h4 1.28879e+06
RNR1493 PAD_P__h16 PAD_P__h5 574977
RNR1494 PAD_P__h16 PAD_P__h6 262939
RNR1495 PAD_P__h16 PAD_P__h7 111469
RNR1496 PAD_P__h16 PAD_P__h8 50798.5
RNR1497 PAD_P__h16 PAD_P__h9 24913.7
RNR1498 PAD_P__h17 PAD_P__h18 347.771
RNR1499 PAD_P__h17 PAD_P__h19 376.935
RNR1500 PAD_P__h17 PAD_P__h20 400.18
RNR1501 PAD_P__h17 PAD_P__h21 425.988
RNR1502 PAD_P__h17 PAD_P__h22 453.744
RNR1503 PAD_P__h17 PAD_P__h23 475.805
RNR1504 PAD_P__h17 PAD_P__h24 486.625
RNR1505 PAD_P__h17 PAD_P__h0 2.873e+07
RNR1506 PAD_P__h17 PAD_P__h1 1.59918e+07
RNR1507 PAD_P__h17 PAD_P__h2 7.14507e+06
RNR1508 PAD_P__h17 PAD_P__h3 3.26398e+06
RNR1509 PAD_P__h17 PAD_P__h4 1.38572e+06
RNR1510 PAD_P__h17 PAD_P__h5 618221
RNR1511 PAD_P__h17 PAD_P__h6 282714
RNR1512 PAD_P__h17 PAD_P__h7 119853
RNR1513 PAD_P__h17 PAD_P__h8 54619.2
RNR1514 PAD_P__h17 PAD_P__h9 26787.7
RNR1515 PAD_P__h18 PAD_P__h19 302.618
RNR1516 PAD_P__h18 PAD_P__h20 326.385
RNR1517 PAD_P__h18 PAD_P__h21 348.953
RNR1518 PAD_P__h18 PAD_P__h22 371.702
RNR1519 PAD_P__h18 PAD_P__h23 389.774
RNR1520 PAD_P__h18 PAD_P__h24 398.638
RNR1521 PAD_P__h18 PAD_P__h0 3.07802e+07
RNR1522 PAD_P__h18 PAD_P__h1 1.7133e+07
RNR1523 PAD_P__h18 PAD_P__h2 7.65496e+06
RNR1524 PAD_P__h18 PAD_P__h3 3.49691e+06
RNR1525 PAD_P__h18 PAD_P__h4 1.48461e+06
RNR1526 PAD_P__h18 PAD_P__h5 662338
RNR1527 PAD_P__h18 PAD_P__h6 302889
RNR1528 PAD_P__h18 PAD_P__h7 128406
RNR1529 PAD_P__h18 PAD_P__h8 58517
RNR1530 PAD_P__h18 PAD_P__h9 28699.4
RNR1531 PAD_P__h19 PAD_P__h20 272.725
RNR1532 PAD_P__h19 PAD_P__h21 294.855
RNR1533 PAD_P__h19 PAD_P__h22 314.105
RNR1534 PAD_P__h19 PAD_P__h23 329.378
RNR1535 PAD_P__h19 PAD_P__h24 336.867
RNR1536 PAD_P__h19 PAD_P__h0 3.25544e+07
RNR1537 PAD_P__h19 PAD_P__h1 1.81205e+07
RNR1538 PAD_P__h19 PAD_P__h2 8.09619e+06
RNR1539 PAD_P__h19 PAD_P__h3 3.69847e+06
RNR1540 PAD_P__h19 PAD_P__h4 1.57018e+06
RNR1541 PAD_P__h19 PAD_P__h5 700516
RNR1542 PAD_P__h19 PAD_P__h6 320348
RNR1543 PAD_P__h19 PAD_P__h7 135807
RNR1544 PAD_P__h19 PAD_P__h8 61890
RNR1545 PAD_P__h19 PAD_P__h9 30353.7
RNR1546 PAD_P__h20 PAD_P__h21 248.125
RNR1547 PAD_P__h20 PAD_P__h22 264.389
RNR1548 PAD_P__h20 PAD_P__h23 277.244
RNR1549 PAD_P__h20 PAD_P__h24 283.548
RNR1550 PAD_P__h20 PAD_P__h0 3.42773e+07
RNR1551 PAD_P__h20 PAD_P__h1 1.90795e+07
RNR1552 PAD_P__h20 PAD_P__h2 8.52466e+06
RNR1553 PAD_P__h20 PAD_P__h3 3.89421e+06
RNR1554 PAD_P__h20 PAD_P__h4 1.65328e+06
RNR1555 PAD_P__h20 PAD_P__h5 737589
RNR1556 PAD_P__h20 PAD_P__h6 337302
RNR1557 PAD_P__h20 PAD_P__h7 142994
RNR1558 PAD_P__h20 PAD_P__h8 65165.3
RNR1559 PAD_P__h20 PAD_P__h9 31960.1
RNR1560 PAD_P__h21 PAD_P__h22 212.213
RNR1561 PAD_P__h21 PAD_P__h23 222.531
RNR1562 PAD_P__h21 PAD_P__h24 227.591
RNR1563 PAD_P__h21 PAD_P__h0 3.64058e+07
RNR1564 PAD_P__h21 PAD_P__h1 2.02643e+07
RNR1565 PAD_P__h21 PAD_P__h2 9.05402e+06
RNR1566 PAD_P__h21 PAD_P__h3 4.13602e+06
RNR1567 PAD_P__h21 PAD_P__h4 1.75595e+06
RNR1568 PAD_P__h21 PAD_P__h5 783391
RNR1569 PAD_P__h21 PAD_P__h6 358247
RNR1570 PAD_P__h21 PAD_P__h7 151874
RNR1571 PAD_P__h21 PAD_P__h8 69211.9
RNR1572 PAD_P__h21 PAD_P__h9 33944.7
RNR1573 PAD_P__h22 PAD_P__h23 175.527
RNR1574 PAD_P__h22 PAD_P__h24 179.519
RNR1575 PAD_P__h22 PAD_P__h0 3.87771e+07
RNR1576 PAD_P__h22 PAD_P__h1 2.15842e+07
RNR1577 PAD_P__h22 PAD_P__h2 9.64377e+06
RNR1578 PAD_P__h22 PAD_P__h3 4.40543e+06
RNR1579 PAD_P__h22 PAD_P__h4 1.87032e+06
RNR1580 PAD_P__h22 PAD_P__h5 834418
RNR1581 PAD_P__h22 PAD_P__h6 381582
RNR1582 PAD_P__h22 PAD_P__h7 161767
RNR1583 PAD_P__h22 PAD_P__h8 73720.1
RNR1584 PAD_P__h22 PAD_P__h9 36155.8
RNR1585 PAD_P__h23 PAD_P__h24 143.138
RNR1586 PAD_P__h23 PAD_P__h0 4.06625e+07
RNR1587 PAD_P__h23 PAD_P__h1 2.26337e+07
RNR1588 PAD_P__h23 PAD_P__h2 1.01127e+07
RNR1589 PAD_P__h23 PAD_P__h3 4.61963e+06
RNR1590 PAD_P__h23 PAD_P__h4 1.96126e+06
RNR1591 PAD_P__h23 PAD_P__h5 874989
RNR1592 PAD_P__h23 PAD_P__h6 400135
RNR1593 PAD_P__h23 PAD_P__h7 169632
RNR1594 PAD_P__h23 PAD_P__h8 77304.5
RNR1595 PAD_P__h23 PAD_P__h9 37913.7
RNR1596 PAD_P__h24 PAD_P__h0 4.15871e+07
RNR1597 PAD_P__h24 PAD_P__h1 2.31483e+07
RNR1598 PAD_P__h24 PAD_P__h2 1.03426e+07
RNR1599 PAD_P__h24 PAD_P__h3 4.72467e+06
RNR1600 PAD_P__h24 PAD_P__h4 2.00586e+06
RNR1601 PAD_P__h24 PAD_P__h5 894885
RNR1602 PAD_P__h24 PAD_P__h6 409233
RNR1603 PAD_P__h24 PAD_P__h7 173489
RNR1604 PAD_P__h24 PAD_P__h8 79062.3
RNR1605 PAD_P__h24 PAD_P__h9 38775.8
RNR1606 PAD_P__h0 PAD_P__h1 1628.02
RNR1607 PAD_P__h0 PAD_P__h2 3836.7
RNR1608 PAD_P__h0 PAD_P__h3 8419.87
RNR1609 PAD_P__h0 PAD_P__h4 20072.2
RNR1610 PAD_P__h0 PAD_P__h5 44330
RNR1611 PAD_P__h0 PAD_P__h6 97252.7
RNR1612 PAD_P__h0 PAD_P__h7 229242
RNR1613 PAD_P__h0 PAD_P__h8 507442
RNR1614 PAD_P__h0 PAD_P__h9 1.23411e+06
RNR1615 PAD_P__h1 PAD_P__h2 2130.9
RNR1616 PAD_P__h1 PAD_P__h3 4683.83
RNR1617 PAD_P__h1 PAD_P__h4 11170.9
RNR1618 PAD_P__h1 PAD_P__h5 24673.9
RNR1619 PAD_P__h1 PAD_P__h6 54132.3
RNR1620 PAD_P__h1 PAD_P__h7 127601
RNR1621 PAD_P__h1 PAD_P__h8 282453
RNR1622 PAD_P__h1 PAD_P__h9 686934
RNR1623 PAD_P__h2 PAD_P__h3 2088.22
RNR1624 PAD_P__h2 PAD_P__h4 4988.41
RNR1625 PAD_P__h2 PAD_P__h5 11022.4
RNR1626 PAD_P__h2 PAD_P__h6 24185
RNR1627 PAD_P__h2 PAD_P__h7 57011
RNR1628 PAD_P__h2 PAD_P__h8 126199
RNR1629 PAD_P__h2 PAD_P__h9 306920
RNR1630 PAD_P__h3 PAD_P__h4 2274.48
RNR1631 PAD_P__h3 PAD_P__h5 5032.35
RNR1632 PAD_P__h3 PAD_P__h6 11046.3
RNR1633 PAD_P__h3 PAD_P__h7 26042.5
RNR1634 PAD_P__h3 PAD_P__h8 57649.1
RNR1635 PAD_P__h3 PAD_P__h9 140206
RNR1636 PAD_P__h4 PAD_P__h5 2131.39
RNR1637 PAD_P__h4 PAD_P__h6 4686.49
RNR1638 PAD_P__h4 PAD_P__h7 11054.5
RNR1639 PAD_P__h4 PAD_P__h8 24473.8
RNR1640 PAD_P__h4 PAD_P__h9 59523.5
RNR1641 PAD_P__h5 PAD_P__h6 2085.55
RNR1642 PAD_P__h5 PAD_P__h7 4928.86
RNR1643 PAD_P__h5 PAD_P__h8 10916.8
RNR1644 PAD_P__h5 PAD_P__h9 26554.5
RNR1645 PAD_P__h6 PAD_P__h7 2248.94
RNR1646 PAD_P__h6 PAD_P__h8 4989.17
RNR1647 PAD_P__h6 PAD_P__h9 12141.5
RNR1648 PAD_P__h7 PAD_P__h8 2109.65
RNR1649 PAD_P__h7 PAD_P__h9 5143.94
RNR1650 PAD_P__h8 PAD_P__h9 2339.85
RNR1651 RX_P RX_P__mim 238.281
RNR1652 RX_P RX_P__dev 211.354
RNR1653 RX_P RX_P__dev 255.701
RNR1654 RX_P RX_P__dev 264.074
RNR1655 RX_P__mim RX_P__dev 144.845
RNR1656 RX_P__mim RX_P__dev 162.641
RNR1657 RX_P__mim RX_P__dev 155.85
RNR1658 PAD_N PAD_N__feed 12.6525
RNR1659 PAD_N PAD_N__dio 159
RNR1660 PAD_N PAD_N__dio 143.106
RNR1661 PAD_N PAD_N__dio 130.279
RNR1662 PAD_N PAD_N__dio 121.322
RNR1663 PAD_N PAD_N__dio 207.335
RNR1664 PAD_N PAD_N__dio 186.622
RNR1665 PAD_N PAD_N__dio 169.96
RNR1666 PAD_N PAD_N__dio 158.553
RNR1667 PAD_N PAD_N__dio 278.153
RNR1668 PAD_N PAD_N__dio 250.376
RNR1669 PAD_N PAD_N__dio 228.069
RNR1670 PAD_N PAD_N__dio 212.972
RNR1671 PAD_N__feed PAD_N__mim 0.799162
RNR1672 PAD_N__feed PAD_N__h0 157.433
RNR1673 PAD_N__feed PAD_N__h1 318.005
RNR1674 PAD_N__feed PAD_N__h2 731.245
RNR1675 PAD_N__feed PAD_N__h3 1595.31
RNR1676 PAD_N__feed PAD_N__h4 3796.67
RNR1677 PAD_N__feed PAD_N__h5 8381.84
RNR1678 PAD_N__feed PAD_N__h6 18386.5
RNR1679 PAD_N__feed PAD_N__h7 43338.9
RNR1680 PAD_N__feed PAD_N__h8 95934.2
RNR1681 PAD_N__feed PAD_N__h9 233318
RNR1682 PAD_N__feed PAD_N__h10 505438
RNR1683 PAD_N__feed PAD_N__h11 1.07167e+06
RNR1684 PAD_N__feed PAD_N__h12 2.08419e+06
RNR1685 PAD_N__feed PAD_N__h13 3.23705e+06
RNR1686 PAD_N__feed PAD_N__h14 4.03213e+06
RNR1687 PAD_N__feed PAD_N__h15 4.61816e+06
RNR1688 PAD_N__feed PAD_N__h16 5.05194e+06
RNR1689 PAD_N__feed PAD_N__h17 5.43188e+06
RNR1690 PAD_N__feed PAD_N__h18 5.81951e+06
RNR1691 PAD_N__feed PAD_N__h19 6.15495e+06
RNR1692 PAD_N__feed PAD_N__h20 6.48068e+06
RNR1693 PAD_N__feed PAD_N__h21 6.88311e+06
RNR1694 PAD_N__feed PAD_N__h22 7.33146e+06
RNR1695 PAD_N__feed PAD_N__h23 7.68792e+06
RNR1696 PAD_N__feed PAD_N__h24 7.86276e+06
RNR1697 PAD_N__feed PAD_N__dio 38.9219
RNR1698 PAD_N__feed PAD_N__dio 35.031
RNR1699 PAD_N__feed PAD_N__dio 31.8911
RNR1700 PAD_N__feed PAD_N__dio 29.6985
RNR1701 PAD_N__feed PAD_N__dio 50.7538
RNR1702 PAD_N__feed PAD_N__dio 45.6835
RNR1703 PAD_N__feed PAD_N__dio 41.6046
RNR1704 PAD_N__feed PAD_N__dio 38.8125
RNR1705 PAD_N__feed PAD_N__dio 68.0894
RNR1706 PAD_N__feed PAD_N__dio 61.29
RNR1707 PAD_N__feed PAD_N__dio 55.8294
RNR1708 PAD_N__feed PAD_N__dio 52.1338
RNR1709 PAD_N__mim PAD_N__h0 15.2933
RNR1710 PAD_N__mim PAD_N__h1 14.6074
RNR1711 PAD_N__mim PAD_N__h2 14.2518
RNR1712 PAD_N__mim PAD_N__h3 14.1108
RNR1713 PAD_N__mim PAD_N__h4 14.0407
RNR1714 PAD_N__mim PAD_N__h5 14.0257
RNR1715 PAD_N__mim PAD_N__h6 14.0137
RNR1716 PAD_N__mim PAD_N__h7 14.0153
RNR1717 PAD_N__mim PAD_N__h8 14.0289
RNR1718 PAD_N__mim PAD_N__h9 13.2653
RNR1719 PAD_N__mim PAD_N__h10 14.4044
RNR1720 PAD_N__mim PAD_N__h11 14.6833
RNR1721 PAD_N__mim PAD_N__h12 15.2333
RNR1722 PAD_N__mim PAD_N__h13 16.3382
RNR1723 PAD_N__mim PAD_N__h14 17.6149
RNR1724 PAD_N__mim PAD_N__h15 19.1128
RNR1725 PAD_N__mim PAD_N__h16 20.5552
RNR1726 PAD_N__mim PAD_N__h17 21.9767
RNR1727 PAD_N__mim PAD_N__h18 23.4973
RNR1728 PAD_N__mim PAD_N__h19 24.8374
RNR1729 PAD_N__mim PAD_N__h20 26.1468
RNR1730 PAD_N__mim PAD_N__h21 27.769
RNR1731 PAD_N__mim PAD_N__h22 29.5778
RNR1732 PAD_N__mim PAD_N__h23 31.0159
RNR1733 PAD_N__mim PAD_N__h24 31.7212
RNR1734 PAD_N__h0 PAD_N__h1 1652.83
RNR1735 PAD_N__h0 PAD_N__h2 3896.68
RNR1736 PAD_N__h0 PAD_N__h3 8552.43
RNR1737 PAD_N__h0 PAD_N__h4 20389
RNR1738 PAD_N__h0 PAD_N__h5 45030.7
RNR1739 PAD_N__h0 PAD_N__h6 98792.3
RNR1740 PAD_N__h0 PAD_N__h7 232873
RNR1741 PAD_N__h0 PAD_N__h8 515487
RNR1742 PAD_N__h0 PAD_N__h9 1.2537e+06
RNR1743 PAD_N__h0 PAD_N__h10 2.7159e+06
RNR1744 PAD_N__h0 PAD_N__h11 5.75846e+06
RNR1745 PAD_N__h0 PAD_N__h12 1.11991e+07
RNR1746 PAD_N__h0 PAD_N__h13 1.73938e+07
RNR1747 PAD_N__h0 PAD_N__h14 2.16661e+07
RNR1748 PAD_N__h0 PAD_N__h15 2.4815e+07
RNR1749 PAD_N__h0 PAD_N__h16 2.71459e+07
RNR1750 PAD_N__h0 PAD_N__h17 2.91875e+07
RNR1751 PAD_N__h0 PAD_N__h18 3.12703e+07
RNR1752 PAD_N__h0 PAD_N__h19 3.30728e+07
RNR1753 PAD_N__h0 PAD_N__h20 3.4823e+07
RNR1754 PAD_N__h0 PAD_N__h21 3.69854e+07
RNR1755 PAD_N__h0 PAD_N__h22 3.93946e+07
RNR1756 PAD_N__h0 PAD_N__h23 4.13099e+07
RNR1757 PAD_N__h0 PAD_N__h24 4.22494e+07
RNR1758 PAD_N__h1 PAD_N__h2 2140.04
RNR1759 PAD_N__h1 PAD_N__h3 4704.14
RNR1760 PAD_N__h1 PAD_N__h4 11219.6
RNR1761 PAD_N__h1 PAD_N__h5 24781.9
RNR1762 PAD_N__h1 PAD_N__h6 54370.4
RNR1763 PAD_N__h1 PAD_N__h7 128163
RNR1764 PAD_N__h1 PAD_N__h8 283702
RNR1765 PAD_N__h1 PAD_N__h9 689984
RNR1766 PAD_N__h1 PAD_N__h10 1.49472e+06
RNR1767 PAD_N__h1 PAD_N__h11 3.16921e+06
RNR1768 PAD_N__h1 PAD_N__h12 6.16351e+06
RNR1769 PAD_N__h1 PAD_N__h13 9.57283e+06
RNR1770 PAD_N__h1 PAD_N__h14 1.19241e+07
RNR1771 PAD_N__h1 PAD_N__h15 1.36571e+07
RNR1772 PAD_N__h1 PAD_N__h16 1.49399e+07
RNR1773 PAD_N__h1 PAD_N__h17 1.60635e+07
RNR1774 PAD_N__h1 PAD_N__h18 1.72099e+07
RNR1775 PAD_N__h1 PAD_N__h19 1.82019e+07
RNR1776 PAD_N__h1 PAD_N__h20 1.91651e+07
RNR1777 PAD_N__h1 PAD_N__h21 2.03552e+07
RNR1778 PAD_N__h1 PAD_N__h22 2.16811e+07
RNR1779 PAD_N__h1 PAD_N__h23 2.27352e+07
RNR1780 PAD_N__h1 PAD_N__h24 2.32523e+07
RNR1781 PAD_N__h2 PAD_N__h3 2090.06
RNR1782 PAD_N__h2 PAD_N__h4 4992.88
RNR1783 PAD_N__h2 PAD_N__h5 11032.5
RNR1784 PAD_N__h2 PAD_N__h6 24207.6
RNR1785 PAD_N__h2 PAD_N__h7 57064.6
RNR1786 PAD_N__h2 PAD_N__h8 126319
RNR1787 PAD_N__h2 PAD_N__h9 307219
RNR1788 PAD_N__h2 PAD_N__h10 665530
RNR1789 PAD_N__h2 PAD_N__h11 1.41111e+06
RNR1790 PAD_N__h2 PAD_N__h12 2.74434e+06
RNR1791 PAD_N__h2 PAD_N__h13 4.26235e+06
RNR1792 PAD_N__h2 PAD_N__h14 5.30927e+06
RNR1793 PAD_N__h2 PAD_N__h15 6.08091e+06
RNR1794 PAD_N__h2 PAD_N__h16 6.65209e+06
RNR1795 PAD_N__h2 PAD_N__h17 7.15238e+06
RNR1796 PAD_N__h2 PAD_N__h18 7.66279e+06
RNR1797 PAD_N__h2 PAD_N__h19 8.10447e+06
RNR1798 PAD_N__h2 PAD_N__h20 8.53338e+06
RNR1799 PAD_N__h2 PAD_N__h21 9.06326e+06
RNR1800 PAD_N__h2 PAD_N__h22 9.65362e+06
RNR1801 PAD_N__h2 PAD_N__h23 1.0123e+07
RNR1802 PAD_N__h2 PAD_N__h24 1.03532e+07
RNR1803 PAD_N__h3 PAD_N__h4 2275
RNR1804 PAD_N__h3 PAD_N__h5 5033.56
RNR1805 PAD_N__h3 PAD_N__h6 11049.2
RNR1806 PAD_N__h3 PAD_N__h7 26049.5
RNR1807 PAD_N__h3 PAD_N__h8 57665.4
RNR1808 PAD_N__h3 PAD_N__h9 140248
RNR1809 PAD_N__h3 PAD_N__h10 303820
RNR1810 PAD_N__h3 PAD_N__h11 644185
RNR1811 PAD_N__h3 PAD_N__h12 1.25282e+06
RNR1812 PAD_N__h3 PAD_N__h13 1.94581e+06
RNR1813 PAD_N__h3 PAD_N__h14 2.42373e+06
RNR1814 PAD_N__h3 PAD_N__h15 2.776e+06
RNR1815 PAD_N__h3 PAD_N__h16 3.03674e+06
RNR1816 PAD_N__h3 PAD_N__h17 3.26513e+06
RNR1817 PAD_N__h3 PAD_N__h18 3.49814e+06
RNR1818 PAD_N__h3 PAD_N__h19 3.69977e+06
RNR1819 PAD_N__h3 PAD_N__h20 3.89557e+06
RNR1820 PAD_N__h3 PAD_N__h21 4.13747e+06
RNR1821 PAD_N__h3 PAD_N__h22 4.40697e+06
RNR1822 PAD_N__h3 PAD_N__h23 4.62124e+06
RNR1823 PAD_N__h3 PAD_N__h24 4.72634e+06
RNR1824 PAD_N__h4 PAD_N__h5 2131.58
RNR1825 PAD_N__h4 PAD_N__h6 4686.98
RNR1826 PAD_N__h4 PAD_N__h7 11055.7
RNR1827 PAD_N__h4 PAD_N__h8 24476.8
RNR1828 PAD_N__h4 PAD_N__h9 59532
RNR1829 PAD_N__h4 PAD_N__h10 128966
RNR1830 PAD_N__h4 PAD_N__h11 273444
RNR1831 PAD_N__h4 PAD_N__h12 531797
RNR1832 PAD_N__h4 PAD_N__h13 825959
RNR1833 PAD_N__h4 PAD_N__h14 1.02883e+06
RNR1834 PAD_N__h4 PAD_N__h15 1.17836e+06
RNR1835 PAD_N__h4 PAD_N__h16 1.28904e+06
RNR1836 PAD_N__h4 PAD_N__h17 1.38599e+06
RNR1837 PAD_N__h4 PAD_N__h18 1.4849e+06
RNR1838 PAD_N__h4 PAD_N__h19 1.57049e+06
RNR1839 PAD_N__h4 PAD_N__h20 1.6536e+06
RNR1840 PAD_N__h4 PAD_N__h21 1.75628e+06
RNR1841 PAD_N__h4 PAD_N__h22 1.87068e+06
RNR1842 PAD_N__h4 PAD_N__h23 1.96163e+06
RNR1843 PAD_N__h4 PAD_N__h24 2.00625e+06
RNR1844 PAD_N__h5 PAD_N__h6 2085.69
RNR1845 PAD_N__h5 PAD_N__h7 4929.19
RNR1846 PAD_N__h5 PAD_N__h8 10917.7
RNR1847 PAD_N__h5 PAD_N__h9 26557.2
RNR1848 PAD_N__h5 PAD_N__h10 57533
RNR1849 PAD_N__h5 PAD_N__h11 121987
RNR1850 PAD_N__h5 PAD_N__h12 237243
RNR1851 PAD_N__h5 PAD_N__h13 368474
RNR1852 PAD_N__h5 PAD_N__h14 458979
RNR1853 PAD_N__h5 PAD_N__h15 525687
RNR1854 PAD_N__h5 PAD_N__h16 575064
RNR1855 PAD_N__h5 PAD_N__h17 618313
RNR1856 PAD_N__h5 PAD_N__h18 662437
RNR1857 PAD_N__h5 PAD_N__h19 700620
RNR1858 PAD_N__h5 PAD_N__h20 737699
RNR1859 PAD_N__h5 PAD_N__h21 783506
RNR1860 PAD_N__h5 PAD_N__h22 834542
RNR1861 PAD_N__h5 PAD_N__h23 875118
RNR1862 PAD_N__h5 PAD_N__h24 895021
RNR1863 PAD_N__h6 PAD_N__h7 2249.08
RNR1864 PAD_N__h6 PAD_N__h8 4989.55
RNR1865 PAD_N__h6 PAD_N__h9 12142.7
RNR1866 PAD_N__h6 PAD_N__h10 26308.3
RNR1867 PAD_N__h6 PAD_N__h11 55783.3
RNR1868 PAD_N__h6 PAD_N__h12 108489
RNR1869 PAD_N__h6 PAD_N__h13 168502
RNR1870 PAD_N__h6 PAD_N__h14 209890
RNR1871 PAD_N__h6 PAD_N__h15 240396
RNR1872 PAD_N__h6 PAD_N__h16 262976
RNR1873 PAD_N__h6 PAD_N__h17 282754
RNR1874 PAD_N__h6 PAD_N__h18 302932
RNR1875 PAD_N__h6 PAD_N__h19 320393
RNR1876 PAD_N__h6 PAD_N__h20 337349
RNR1877 PAD_N__h6 PAD_N__h21 358297
RNR1878 PAD_N__h6 PAD_N__h22 381636
RNR1879 PAD_N__h6 PAD_N__h23 400191
RNR1880 PAD_N__h6 PAD_N__h24 409293
RNR1881 PAD_N__h7 PAD_N__h8 2109.76
RNR1882 PAD_N__h7 PAD_N__h9 5144.29
RNR1883 PAD_N__h7 PAD_N__h10 11150.2
RNR1884 PAD_N__h7 PAD_N__h11 23645.4
RNR1885 PAD_N__h7 PAD_N__h12 45988.7
RNR1886 PAD_N__h7 PAD_N__h13 71430.3
RNR1887 PAD_N__h7 PAD_N__h14 88976.9
RNR1888 PAD_N__h7 PAD_N__h15 101910
RNR1889 PAD_N__h7 PAD_N__h16 111482
RNR1890 PAD_N__h7 PAD_N__h17 119867
RNR1891 PAD_N__h7 PAD_N__h18 128421
RNR1892 PAD_N__h7 PAD_N__h19 135823
RNR1893 PAD_N__h7 PAD_N__h20 143011
RNR1894 PAD_N__h7 PAD_N__h21 151891
RNR1895 PAD_N__h7 PAD_N__h22 161785
RNR1896 PAD_N__h7 PAD_N__h23 169651
RNR1897 PAD_N__h7 PAD_N__h24 173510
RNR1898 PAD_N__h8 PAD_N__h9 2339.98
RNR1899 PAD_N__h8 PAD_N__h10 5077.95
RNR1900 PAD_N__h8 PAD_N__h11 10772.2
RNR1901 PAD_N__h8 PAD_N__h12 20954.1
RNR1902 PAD_N__h8 PAD_N__h13 32549.3
RNR1903 PAD_N__h8 PAD_N__h14 40546.8
RNR1904 PAD_N__h8 PAD_N__h15 46441.1
RNR1905 PAD_N__h8 PAD_N__h16 50803.8
RNR1906 PAD_N__h8 PAD_N__h17 54624.8
RNR1907 PAD_N__h8 PAD_N__h18 58523
RNR1908 PAD_N__h8 PAD_N__h19 61896.3
RNR1909 PAD_N__h8 PAD_N__h20 65172
RNR1910 PAD_N__h8 PAD_N__h21 69218.9
RNR1911 PAD_N__h8 PAD_N__h22 73727.6
RNR1912 PAD_N__h8 PAD_N__h23 77312.3
RNR1913 PAD_N__h8 PAD_N__h24 79070.6
RNR1914 PAD_N__h9 PAD_N__h10 2485.95
RNR1915 PAD_N__h9 PAD_N__h11 5278.68
RNR1916 PAD_N__h9 PAD_N__h12 10272
RNR1917 PAD_N__h9 PAD_N__h13 15960.1
RNR1918 PAD_N__h9 PAD_N__h14 19884.2
RNR1919 PAD_N__h9 PAD_N__h15 22776
RNR1920 PAD_N__h9 PAD_N__h16 24916
RNR1921 PAD_N__h9 PAD_N__h17 26790.1
RNR1922 PAD_N__h9 PAD_N__h18 28702
RNR1923 PAD_N__h9 PAD_N__h19 30356.4
RNR1924 PAD_N__h9 PAD_N__h20 31962.9
RNR1925 PAD_N__h9 PAD_N__h21 33947.7
RNR1926 PAD_N__h9 PAD_N__h22 36158.9
RNR1927 PAD_N__h9 PAD_N__h23 37917
RNR1928 PAD_N__h9 PAD_N__h24 38779.3
RNR1929 PAD_N__h10 PAD_N__h11 2096.45
RNR1930 PAD_N__h10 PAD_N__h12 4088.77
RNR1931 PAD_N__h10 PAD_N__h13 6362.73
RNR1932 PAD_N__h10 PAD_N__h14 7933.22
RNR1933 PAD_N__h10 PAD_N__h15 9089.87
RNR1934 PAD_N__h10 PAD_N__h16 9944.97
RNR1935 PAD_N__h10 PAD_N__h17 10693.4
RNR1936 PAD_N__h10 PAD_N__h18 11456.7
RNR1937 PAD_N__h10 PAD_N__h19 12117.1
RNR1938 PAD_N__h10 PAD_N__h20 12758.4
RNR1939 PAD_N__h10 PAD_N__h21 13550.6
RNR1940 PAD_N__h10 PAD_N__h22 14433.3
RNR1941 PAD_N__h10 PAD_N__h23 15135
RNR1942 PAD_N__h10 PAD_N__h24 15479.2
RNR1943 PAD_N__h11 PAD_N__h12 1822.84
RNR1944 PAD_N__h11 PAD_N__h13 2852.09
RNR1945 PAD_N__h11 PAD_N__h14 3565.85
RNR1946 PAD_N__h11 PAD_N__h15 4090.41
RNR1947 PAD_N__h11 PAD_N__h16 4476.86
RNR1948 PAD_N__h11 PAD_N__h17 4814.37
RNR1949 PAD_N__h11 PAD_N__h18 5158.25
RNR1950 PAD_N__h11 PAD_N__h19 5455.67
RNR1951 PAD_N__h11 PAD_N__h20 5744.43
RNR1952 PAD_N__h11 PAD_N__h21 6101.14
RNR1953 PAD_N__h11 PAD_N__h22 6498.55
RNR1954 PAD_N__h11 PAD_N__h23 6814.52
RNR1955 PAD_N__h11 PAD_N__h24 6969.5
RNR1956 PAD_N__h12 PAD_N__h13 1331.99
RNR1957 PAD_N__h12 PAD_N__h14 1682.06
RNR1958 PAD_N__h12 PAD_N__h15 1937.58
RNR1959 PAD_N__h12 PAD_N__h16 2123.55
RNR1960 PAD_N__h12 PAD_N__h17 2284.69
RNR1961 PAD_N__h12 PAD_N__h18 2448.29
RNR1962 PAD_N__h12 PAD_N__h19 2589.57
RNR1963 PAD_N__h12 PAD_N__h20 2726.68
RNR1964 PAD_N__h12 PAD_N__h21 2896.01
RNR1965 PAD_N__h12 PAD_N__h22 3084.65
RNR1966 PAD_N__h12 PAD_N__h23 3234.63
RNR1967 PAD_N__h12 PAD_N__h24 3308.19
RNR1968 PAD_N__h13 PAD_N__h14 826.32
RNR1969 PAD_N__h13 PAD_N__h15 973.007
RNR1970 PAD_N__h13 PAD_N__h16 1074.24
RNR1971 PAD_N__h13 PAD_N__h17 1158.62
RNR1972 PAD_N__h13 PAD_N__h18 1242.7
RNR1973 PAD_N__h13 PAD_N__h19 1314.75
RNR1974 PAD_N__h13 PAD_N__h20 1384.47
RNR1975 PAD_N__h13 PAD_N__h21 1470.49
RNR1976 PAD_N__h13 PAD_N__h22 1566.27
RNR1977 PAD_N__h13 PAD_N__h23 1642.42
RNR1978 PAD_N__h13 PAD_N__h24 1679.78
RNR1979 PAD_N__h14 PAD_N__h15 608.072
RNR1980 PAD_N__h14 PAD_N__h16 685.733
RNR1981 PAD_N__h14 PAD_N__h17 745.024
RNR1982 PAD_N__h14 PAD_N__h18 801.211
RNR1983 PAD_N__h14 PAD_N__h19 848.309
RNR1984 PAD_N__h14 PAD_N__h20 893.525
RNR1985 PAD_N__h14 PAD_N__h21 949.101
RNR1986 PAD_N__h14 PAD_N__h22 1010.92
RNR1987 PAD_N__h14 PAD_N__h23 1060.08
RNR1988 PAD_N__h14 PAD_N__h24 1084.18
RNR1989 PAD_N__h15 PAD_N__h16 470.873
RNR1990 PAD_N__h15 PAD_N__h17 522.993
RNR1991 PAD_N__h15 PAD_N__h18 567.052
RNR1992 PAD_N__h15 PAD_N__h19 601.804
RNR1993 PAD_N__h15 PAD_N__h20 634.379
RNR1994 PAD_N__h15 PAD_N__h21 673.98
RNR1995 PAD_N__h15 PAD_N__h22 717.883
RNR1996 PAD_N__h15 PAD_N__h23 752.787
RNR1997 PAD_N__h15 PAD_N__h24 769.908
RNR1998 PAD_N__h16 PAD_N__h17 395.843
RNR1999 PAD_N__h16 PAD_N__h18 437.753
RNR2000 PAD_N__h16 PAD_N__h19 467.284
RNR2001 PAD_N__h16 PAD_N__h20 493.536
RNR2002 PAD_N__h16 PAD_N__h21 524.623
RNR2003 PAD_N__h16 PAD_N__h22 558.799
RNR2004 PAD_N__h16 PAD_N__h23 585.968
RNR2005 PAD_N__h16 PAD_N__h24 599.295
RNR2006 PAD_N__h17 PAD_N__h18 347.776
RNR2007 PAD_N__h17 PAD_N__h19 376.939
RNR2008 PAD_N__h17 PAD_N__h20 400.184
RNR2009 PAD_N__h17 PAD_N__h21 425.992
RNR2010 PAD_N__h17 PAD_N__h22 453.748
RNR2011 PAD_N__h17 PAD_N__h23 475.81
RNR2012 PAD_N__h17 PAD_N__h24 486.631
RNR2013 PAD_N__h18 PAD_N__h19 302.622
RNR2014 PAD_N__h18 PAD_N__h20 326.389
RNR2015 PAD_N__h18 PAD_N__h21 348.956
RNR2016 PAD_N__h18 PAD_N__h22 371.705
RNR2017 PAD_N__h18 PAD_N__h23 389.778
RNR2018 PAD_N__h18 PAD_N__h24 398.642
RNR2019 PAD_N__h19 PAD_N__h20 272.728
RNR2020 PAD_N__h19 PAD_N__h21 294.858
RNR2021 PAD_N__h19 PAD_N__h22 314.108
RNR2022 PAD_N__h19 PAD_N__h23 329.381
RNR2023 PAD_N__h19 PAD_N__h24 336.872
RNR2024 PAD_N__h20 PAD_N__h21 248.128
RNR2025 PAD_N__h20 PAD_N__h22 264.392
RNR2026 PAD_N__h20 PAD_N__h23 277.247
RNR2027 PAD_N__h20 PAD_N__h24 283.552
RNR2028 PAD_N__h21 PAD_N__h22 212.216
RNR2029 PAD_N__h21 PAD_N__h23 222.534
RNR2030 PAD_N__h21 PAD_N__h24 227.595
RNR2031 PAD_N__h22 PAD_N__h23 175.529
RNR2032 PAD_N__h22 PAD_N__h24 179.521
RNR2033 PAD_N__h23 PAD_N__h24 143.14
RNR2034 RX_N RX_N__mim 237.868
RNR2035 RX_N RX_N__dev 255.875
RNR2036 RX_N RX_N__dev 264.251
RNR2037 RX_N RX_N__dev 211.555
RNR2038 RX_N__mim RX_N__dev 162.615
RNR2039 RX_N__mim RX_N__dev 155.834
RNR2040 RX_N__mim RX_N__dev 144.852
RTUP16 a_85492_91054_r# a_85492_91054# 33.978
RTUP18 a_87628_91054_r# a_87628_91054# 34.4035
RTUN22 a_91900_152846_r# a_91900_152846# 35.236
RTUN14 a_83356_152846_r# a_83356_152846# 33.5302
RTUN5 a_73744_152046_r# a_73744_152046# 30.3699
RTUN7 a_75880_152046_r# a_75880_152046# 30.7915
RTUP17 a_86560_91054_r# a_86560_91054# 34.1902
RTUP3 a_71608_90254_r# a_71608_90254# 29.9946
RTUP24 a_94036_91054_r# a_94036_91054# 35.6833
RTUP9 a_78016_90254_r# a_78016_90254# 31.2372
RTUN19 a_88696_152846_r# a_88696_152846# 34.5932
RTUN9 a_78016_152046_r# a_78016_152046# 31.2152
RTUN11 a_80152_152846_r# a_80152_152846# 32.8942
RTUN1 a_69448_149284_r# a_69448_149284# 14.6008
RTUP22 a_91900_91054_r# a_91900_91054# 35.2586
RTUP15 a_84424_91054_r# a_84424_91054# 33.7659
RTUP0 a_68216_96914_r# a_68216_96914# 14.4314
RTUN12 a_81220_152846_r# a_81220_152846# 33.105
RTUP13 a_82288_91054_r# a_82288_91054# 33.3409
RTUP20 a_89764_91054_r# a_89764_91054# 34.8282
RTUP2 a_70540_90254_r# a_70540_90254# 44.9763
RTUN6 a_74812_152046_r# a_74812_152046# 30.5797
RTUP8 a_76948_90254_r# a_76948_90254# 31.0257
RTUP11 a_80152_91054_r# a_80152_91054# 32.9169
RTUN21 a_90832_152846_r# a_90832_152846# 35.0078
RTUN23 a_92968_152846_r# a_92968_152846# 35.4483
RTUN15 a_84424_152846_r# a_84424_152846# 33.7432
RTUP4 a_72676_90254_r# a_72676_90254# 30.1821
RTUN2 a_70540_152046_r# a_70540_152046# 44.9513
RTUN20 a_89764_152846_r# a_89764_152846# 34.8056
RTUN13 a_82288_152846_r# a_82288_152846# 33.3183
RTUN4 a_72676_152046_r# a_72676_152046# 30.1601
RTUP21 a_90832_91054_r# a_90832_91054# 35.0314
RTUP23 a_92968_91054_r# a_92968_91054# 35.4709
RTUP1 a_69448_96914_r# a_69448_96914# 14.6258
RTUN16 a_85492_152846_r# a_85492_152846# 33.9554
RTUP14 a_83356_91054_r# a_83356_91054# 33.5529
RTUP6 a_74812_90254_r# a_74812_90254# 30.6017
RTUN10 a_79084_152846_r# a_79084_152846# 32.6742
RTUN0 a_68216_149284_r# a_68216_149284# 14.4063
RTUP12 a_81220_91054_r# a_81220_91054# 33.1276
RTUN3 a_71608_152046_r# a_71608_152046# 29.9726
RTUP19 a_88696_91054_r# a_88696_91054# 34.6158
RTUN24 a_94036_152846_r# a_94036_152846# 35.6607
RTUN18 a_87628_152846_r# a_87628_152846# 34.3808
RTUP10 a_79084_91054_r# a_79084_91054# 32.6968
RTUN17 a_86560_152846_r# a_86560_152846# 34.1676
RTUN8 a_76948_152046_r# a_76948_152046# 31.0037
RTUP5 a_73744_90254_r# a_73744_90254# 30.3919
RTUP7 a_75880_90254_r# a_75880_90254# 30.8135
.ends
