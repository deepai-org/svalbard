.subckt hs_protected_pad VSS VDD TERM_VCM TERM_ENABLE TERM_TRIM0 TERM_TRIM1 TERM_TRIM2 TERM_TRIM3 VBIAS RX_P RX_N PAD_P PAD_N
XPHYSICAL ESD_RAIL VSS VDD TERM_VCM TERM_ENABLE TERM_TRIM0 TERM_TRIM1 TERM_TRIM2 TERM_TRIM3 VBIAS RX_P RX_N PAD_P PAD_N pad_hspad_flat
.ends hs_protected_pad
* NGSPICE file created from pad_hspad_flat.ext - technology: gf180mcuD

.subckt pad_hspad_flat ESD_RAIL VSS VDD TERM_VCM TERM_ENABLE TERM_TRIM0 TERM_TRIM1
+ TERM_TRIM2 TERM_TRIM3 VBIAS RX_P RX_N PAD_P PAD_N
X0 a_74812_152046# TERM_ENABLE TERM_VCM VSS nfet_06v0 ad=8.8p pd=40.88u as=8.8p ps=40.88u w=20u l=0.7u
X1 ESD_RAIL a_1852_148519# VSS VSS nfet_06v0 ad=13.936p pd=54.12u as=13.936p ps=54.12u w=53.6u l=0.7u
X2 ESD_RAIL a_1852_148519# VSS VSS nfet_06v0 ad=13.936p pd=54.12u as=13.936p ps=54.12u w=53.6u l=0.7u
X3 ESD_RAIL a_2245_90628# VSS VSS nfet_06v0 ad=22p pd=0.10088m as=13p ps=50.52u w=50u l=0.7u
X4 a_1005_133505# a_13878_133225# ESD_RAIL ppolyf_u r_width=0.8u r_length=63.855u
X5 a_72676_152046# TERM_ENABLE TERM_VCM VSS nfet_06v0 ad=8.8p pd=40.88u as=8.8p ps=40.88u w=20u l=0.7u
X6 ESD_RAIL a_1852_148519# VSS VSS nfet_06v0 ad=13.936p pd=54.12u as=23.584p ps=0.10808m w=53.6u l=0.7u
X7 ESD_RAIL a_1852_148519# VSS VSS nfet_06v0 ad=13.936p pd=54.12u as=13.936p ps=54.12u w=53.6u l=0.7u
X8 VSS a_1852_148519# ESD_RAIL VSS nfet_06v0 ad=13.936p pd=54.12u as=13.936p ps=54.12u w=53.6u l=0.7u
X9 RX_N VBIAS VSS ppolyf_u_1k r_width=1u r_length=40u
X10 VSS a_2245_90628# ESD_RAIL VSS nfet_06v0 ad=13p pd=50.52u as=13p ps=50.52u w=50u l=0.7u
X11 VSS a_1852_148519# ESD_RAIL VSS nfet_06v0 ad=13.936p pd=54.12u as=13.936p ps=54.12u w=53.6u l=0.7u
X12 ESD_RAIL a_1852_148519# VSS VSS nfet_06v0 ad=13.936p pd=54.12u as=13.936p ps=54.12u w=53.6u l=0.7u
D0 PAD_P ESD_RAIL diode_pd2nw_06v0 pj=51.8u area=22.5p
X13 VSS a_1852_148519# ESD_RAIL VSS nfet_06v0 ad=13.936p pd=54.12u as=13.936p ps=54.12u w=53.6u l=0.7u
X14 ESD_RAIL a_2245_90628# VSS VSS nfet_06v0 ad=22p pd=0.10088m as=13p ps=50.52u w=50u l=0.7u
X15 a_80152_152846# TERM_TRIM1 TERM_VCM VSS nfet_06v0 ad=5.28p pd=24.88u as=5.28p ps=24.88u w=12u l=0.7u
X16 PAD_P a_85492_91054# VSS ppolyf_u r_width=2u r_length=1u
X17 PAD_P a_87628_91054# VSS ppolyf_u r_width=2u r_length=1u
X18 a_75880_90254# TERM_ENABLE TERM_VCM VSS nfet_06v0 ad=8.8p pd=40.88u as=8.8p ps=40.88u w=20u l=0.7u
X19 ESD_RAIL a_4789_117064# a_2245_90628# ESD_RAIL pfet_06v0 ad=1.3p pd=5.52u as=1.3p ps=5.52u w=5u l=0.7u
X20 a_82288_91054# TERM_TRIM2 TERM_VCM VSS nfet_06v0 ad=5.28p pd=24.88u as=5.28p ps=24.88u w=12u l=0.7u
X21 ESD_RAIL a_1852_148519# VSS VSS nfet_06v0 ad=13.936p pd=54.12u as=13.936p ps=54.12u w=53.6u l=0.7u
X22 ESD_RAIL a_4789_117064# a_2245_90628# ESD_RAIL pfet_06v0 ad=1.3p pd=5.52u as=1.3p ps=5.52u w=5u l=0.7u
X23 ESD_RAIL a_1852_148519# VSS VSS nfet_06v0 ad=13.936p pd=54.12u as=13.936p ps=54.12u w=53.6u l=0.7u
X24 RX_P PAD_P cap_mim_2f0_m4m5_noshield c_width=35u c_length=35u
X25 ESD_RAIL a_2245_90628# VSS VSS nfet_06v0 ad=13p pd=50.52u as=13p ps=50.52u w=50u l=0.7u
X26 a_91900_152846# PAD_N VSS ppolyf_u r_width=2u r_length=1u
X27 VSS a_1852_148519# ESD_RAIL VSS nfet_06v0 ad=13.936p pd=54.12u as=13.936p ps=54.12u w=53.6u l=0.7u
X28 ESD_RAIL a_13878_134345# ESD_RAIL ppolyf_u r_width=0.8u r_length=63.855u
X29 ESD_RAIL a_1852_148519# VSS VSS nfet_06v0 ad=13.936p pd=54.12u as=13.936p ps=54.12u w=53.6u l=0.7u
X30 VSS a_1852_148519# ESD_RAIL VSS nfet_06v0 ad=13.936p pd=54.12u as=13.936p ps=54.12u w=53.6u l=0.7u
X31 ESD_RAIL a_1852_148519# VSS VSS nfet_06v0 ad=13.936p pd=54.12u as=13.936p ps=54.12u w=53.6u l=0.7u
X32 ESD_RAIL a_1852_148519# VSS VSS nfet_06v0 ad=13.936p pd=54.12u as=13.936p ps=54.12u w=53.6u l=0.7u
D1 VSS PAD_P diode_nd2ps_06v0 pj=51.8u area=22.5p
X33 a_83356_152846# PAD_N VSS ppolyf_u r_width=2u r_length=1u
X34 VSS a_1852_148519# ESD_RAIL VSS nfet_06v0 ad=13.936p pd=54.12u as=13.936p ps=54.12u w=53.6u l=0.7u
X35 a_73744_152046# PAD_N VSS ppolyf_u r_width=2u r_length=2.6u
X36 ESD_RAIL a_2245_90628# VSS VSS nfet_06v0 ad=13p pd=50.52u as=13p ps=50.52u w=50u l=0.7u
X37 a_79084_152846# TERM_TRIM0 TERM_VCM VSS nfet_06v0 ad=5.28p pd=24.88u as=5.28p ps=24.88u w=12u l=0.7u
X38 ESD_RAIL a_1852_148519# VSS VSS nfet_06v0 ad=13.936p pd=54.12u as=13.936p ps=54.12u w=53.6u l=0.7u
X39 a_71608_152046# TERM_ENABLE TERM_VCM VSS nfet_06v0 ad=8.8p pd=40.88u as=8.8p ps=40.88u w=20u l=0.7u
X40 VSS a_1852_148519# ESD_RAIL VSS nfet_06v0 ad=13.936p pd=54.12u as=13.936p ps=54.12u w=53.6u l=0.7u
X41 VSS a_2245_90628# ESD_RAIL VSS nfet_06v0 ad=13p pd=50.52u as=22p ps=0.10088m w=50u l=0.7u
X42 VSS a_1852_148519# ESD_RAIL VSS nfet_06v0 ad=23.584p pd=0.10808m as=13.936p ps=54.12u w=53.6u l=0.7u
X43 VSS a_2245_90628# ESD_RAIL VSS nfet_06v0 ad=13p pd=50.52u as=13p ps=50.52u w=50u l=0.7u
X44 VSS a_1852_148519# ESD_RAIL VSS nfet_06v0 ad=13.936p pd=54.12u as=13.936p ps=54.12u w=53.6u l=0.7u
X45 VSS a_1852_148519# ESD_RAIL VSS nfet_06v0 ad=13.936p pd=54.12u as=13.936p ps=54.12u w=53.6u l=0.7u
X46 VSS a_1852_148519# ESD_RAIL VSS nfet_06v0 ad=23.584p pd=0.10808m as=13.936p ps=54.12u w=53.6u l=0.7u
X47 VSS a_2245_90628# ESD_RAIL VSS nfet_06v0 ad=13p pd=50.52u as=13p ps=50.52u w=50u l=0.7u
X48 a_81220_152846# TERM_TRIM1 TERM_VCM VSS nfet_06v0 ad=5.28p pd=24.88u as=5.28p ps=24.88u w=12u l=0.7u
X49 ESD_RAIL a_1852_148519# VSS VSS nfet_06v0 ad=13.936p pd=54.12u as=13.936p ps=54.12u w=53.6u l=0.7u
X50 a_75880_152046# PAD_N VSS ppolyf_u r_width=2u r_length=2.6u
X51 ESD_RAIL a_1852_148519# VSS VSS nfet_06v0 ad=13.936p pd=54.12u as=13.936p ps=54.12u w=53.6u l=0.7u
X52 ESD_RAIL a_2245_90628# VSS VSS nfet_06v0 ad=13p pd=50.52u as=13p ps=50.52u w=50u l=0.7u
X53 a_92968_91054# TERM_TRIM3 TERM_VCM VSS nfet_06v0 ad=5.28p pd=24.88u as=5.28p ps=24.88u w=12u l=0.7u
X54 VSS a_1852_148519# ESD_RAIL VSS nfet_06v0 ad=13.936p pd=54.12u as=13.936p ps=54.12u w=53.6u l=0.7u
D2 PAD_N ESD_RAIL diode_pd2nw_06v0 pj=51.8u area=22.5p
X55 VSS a_1852_148519# ESD_RAIL VSS nfet_06v0 ad=13.936p pd=54.12u as=13.936p ps=54.12u w=53.6u l=0.7u
X56 ESD_RAIL a_1852_148519# VSS VSS nfet_06v0 ad=13.936p pd=54.12u as=13.936p ps=54.12u w=53.6u l=0.7u
X57 ESD_RAIL a_1852_148519# VSS VSS nfet_06v0 ad=13.936p pd=54.12u as=13.936p ps=54.12u w=53.6u l=0.7u
X58 ESD_RAIL a_1852_148519# VSS VSS nfet_06v0 ad=13.936p pd=54.12u as=13.936p ps=54.12u w=53.6u l=0.7u
X59 a_89764_91054# TERM_TRIM3 TERM_VCM VSS nfet_06v0 ad=5.28p pd=24.88u as=5.28p ps=24.88u w=12u l=0.7u
X60 VSS a_1852_148519# ESD_RAIL VSS nfet_06v0 ad=13.936p pd=54.12u as=13.936p ps=54.12u w=53.6u l=0.7u
X61 VSS a_1852_148519# ESD_RAIL VSS nfet_06v0 ad=13.936p pd=54.12u as=13.936p ps=54.12u w=53.6u l=0.7u
X62 VSS a_1852_148519# ESD_RAIL VSS nfet_06v0 ad=23.584p pd=0.10808m as=13.936p ps=54.12u w=53.6u l=0.7u
X63 ESD_RAIL a_1852_148519# VSS VSS nfet_06v0 ad=13.936p pd=54.12u as=13.936p ps=54.12u w=53.6u l=0.7u
X64 ESD_RAIL a_2245_90628# VSS VSS nfet_06v0 ad=13p pd=50.52u as=13p ps=50.52u w=50u l=0.7u
X65 ESD_RAIL a_1005_131545# a_3813_117064# ESD_RAIL pfet_06v0 ad=1.3p pd=5.52u as=1.3p ps=5.52u w=5u l=0.7u
D3 VSS PAD_P diode_nd2ps_06v0 pj=51.8u area=22.5p
D4 PAD_N ESD_RAIL diode_pd2nw_06v0 pj=51.8u area=22.5p
X66 a_84424_91054# TERM_TRIM2 TERM_VCM VSS nfet_06v0 ad=5.28p pd=24.88u as=5.28p ps=24.88u w=12u l=0.7u
X67 ESD_RAIL a_1852_148519# VSS VSS nfet_06v0 ad=13.936p pd=54.12u as=13.936p ps=54.12u w=53.6u l=0.7u
X68 ESD_RAIL a_1852_148519# VSS VSS nfet_06v0 ad=13.936p pd=54.12u as=13.936p ps=54.12u w=53.6u l=0.7u
X69 VSS a_1852_148519# ESD_RAIL VSS nfet_06v0 ad=13.936p pd=54.12u as=13.936p ps=54.12u w=53.6u l=0.7u
X70 PAD_P a_86560_91054# VSS ppolyf_u r_width=2u r_length=1u
X71 VSS a_1852_148519# ESD_RAIL VSS nfet_06v0 ad=13.936p pd=54.12u as=13.936p ps=54.12u w=53.6u l=0.7u
X72 ESD_RAIL a_1852_148519# VSS VSS nfet_06v0 ad=13.936p pd=54.12u as=13.936p ps=54.12u w=53.6u l=0.7u
X73 ESD_RAIL a_1852_148519# VSS VSS nfet_06v0 ad=13.936p pd=54.12u as=13.936p ps=54.12u w=53.6u l=0.7u
X74 PAD_P a_71608_90254# VSS ppolyf_u r_width=2u r_length=2.6u
X75 a_89764_152846# TERM_TRIM3 TERM_VCM VSS nfet_06v0 ad=5.28p pd=24.88u as=5.28p ps=24.88u w=12u l=0.7u
X76 VSS a_2245_90628# ESD_RAIL VSS nfet_06v0 ad=13p pd=50.52u as=13p ps=50.52u w=50u l=0.7u
X77 PAD_P a_94036_91054# VSS ppolyf_u r_width=2u r_length=1u
D5 PAD_N ESD_RAIL diode_pd2nw_06v0 pj=51.8u area=22.5p
X78 PAD_P a_78016_90254# VSS ppolyf_u r_width=2u r_length=2.6u
X79 VSS a_2245_90628# ESD_RAIL VSS nfet_06v0 ad=13p pd=50.52u as=13p ps=50.52u w=50u l=0.7u
X80 VSS a_2245_90628# ESD_RAIL VSS nfet_06v0 ad=13p pd=50.52u as=13p ps=50.52u w=50u l=0.7u
X81 VSS a_1852_148519# ESD_RAIL VSS nfet_06v0 ad=13.936p pd=54.12u as=13.936p ps=54.12u w=53.6u l=0.7u
X82 ESD_RAIL a_1852_148519# VSS VSS nfet_06v0 ad=13.936p pd=54.12u as=13.936p ps=54.12u w=53.6u l=0.7u
X83 VSS a_1852_148519# ESD_RAIL VSS nfet_06v0 ad=13.936p pd=54.12u as=13.936p ps=54.12u w=53.6u l=0.7u
X84 a_79084_91054# TERM_TRIM0 TERM_VCM VSS nfet_06v0 ad=5.28p pd=24.88u as=5.28p ps=24.88u w=12u l=0.7u
X85 ESD_RAIL a_2245_90628# VSS VSS nfet_06v0 ad=13p pd=50.52u as=13p ps=50.52u w=50u l=0.7u
X86 VSS a_1852_148519# ESD_RAIL VSS nfet_06v0 ad=13.936p pd=54.12u as=13.936p ps=54.12u w=53.6u l=0.7u
X87 ESD_RAIL a_1852_148519# VSS VSS nfet_06v0 ad=13.936p pd=54.12u as=13.936p ps=54.12u w=53.6u l=0.7u
X88 ESD_RAIL a_1852_148519# VSS VSS nfet_06v0 ad=13.936p pd=54.12u as=13.936p ps=54.12u w=53.6u l=0.7u
X89 ESD_RAIL a_2245_90628# VSS VSS nfet_06v0 ad=13p pd=50.52u as=13p ps=50.52u w=50u l=0.7u
X90 ESD_RAIL a_2245_90628# VSS VSS nfet_06v0 ad=13p pd=50.52u as=13p ps=50.52u w=50u l=0.7u
X91 a_2245_90628# a_4789_117064# ESD_RAIL ESD_RAIL pfet_06v0 ad=1.3p pd=5.52u as=1.3p ps=5.52u w=5u l=0.7u
X92 ESD_RAIL a_1852_148519# VSS VSS nfet_06v0 ad=13.936p pd=54.12u as=13.936p ps=54.12u w=53.6u l=0.7u
X93 ESD_RAIL a_1852_148519# VSS VSS nfet_06v0 ad=13.936p pd=54.12u as=23.584p ps=0.10808m w=53.6u l=0.7u
X94 ESD_RAIL a_1852_148519# VSS VSS nfet_06v0 ad=13.936p pd=54.12u as=13.936p ps=54.12u w=53.6u l=0.7u
D6 PAD_N ESD_RAIL diode_pd2nw_06v0 pj=51.8u area=22.5p
X95 a_88696_152846# PAD_N VSS ppolyf_u r_width=2u r_length=1u
X96 VSS a_1852_148519# ESD_RAIL VSS nfet_06v0 ad=13.936p pd=54.12u as=13.936p ps=54.12u w=53.6u l=0.7u
X97 a_2245_90628# a_4789_117064# ESD_RAIL ESD_RAIL pfet_06v0 ad=1.3p pd=5.52u as=1.3p ps=5.52u w=5u l=0.7u
X98 VSS a_1852_148519# ESD_RAIL VSS nfet_06v0 ad=13.936p pd=54.12u as=13.936p ps=54.12u w=53.6u l=0.7u
X99 ESD_RAIL a_2245_90628# VSS VSS nfet_06v0 ad=13p pd=50.52u as=13p ps=50.52u w=50u l=0.7u
X100 a_78016_152046# PAD_N VSS ppolyf_u r_width=2u r_length=2.6u
X101 ESD_RAIL a_4789_117064# a_2245_90628# ESD_RAIL pfet_06v0 ad=1.3p pd=5.52u as=1.3p ps=5.52u w=5u l=0.7u
X102 a_80152_152846# PAD_N VSS ppolyf_u r_width=2u r_length=1u
X103 a_1005_132385# a_13878_132105# ESD_RAIL ppolyf_u r_width=0.8u r_length=63.855u
X104 ESD_RAIL a_1852_148519# VSS VSS nfet_06v0 ad=13.936p pd=54.12u as=13.936p ps=54.12u w=53.6u l=0.7u
X105 ESD_RAIL w_71178_112088# VSS ppolyf_u_1k_6p0 r_width=1u r_length=0.47474m
X106 a_69448_149284# PAD_N VSS ppolyf_u r_width=2u r_length=2.6u
X107 a_88696_152846# TERM_TRIM3 TERM_VCM VSS nfet_06v0 ad=5.28p pd=24.88u as=5.28p ps=24.88u w=12u l=0.7u
X108 ESD_RAIL a_1852_148519# VSS VSS nfet_06v0 ad=13.936p pd=54.12u as=13.936p ps=54.12u w=53.6u l=0.7u
X109 VSS a_1852_148519# ESD_RAIL VSS nfet_06v0 ad=13.936p pd=54.12u as=13.936p ps=54.12u w=53.6u l=0.7u
X110 VSS a_2245_90628# ESD_RAIL VSS nfet_06v0 ad=13p pd=50.52u as=13p ps=50.52u w=50u l=0.7u
X111 VSS a_1852_148519# ESD_RAIL VSS nfet_06v0 ad=13.936p pd=54.12u as=13.936p ps=54.12u w=53.6u l=0.7u
X112 VSS a_1852_148519# ESD_RAIL VSS nfet_06v0 ad=13.936p pd=54.12u as=13.936p ps=54.12u w=53.6u l=0.7u
X113 PAD_P a_91900_91054# VSS ppolyf_u r_width=2u r_length=1u
X114 ESD_RAIL a_4789_117064# a_2245_90628# ESD_RAIL pfet_06v0 ad=1.3p pd=5.52u as=1.3p ps=5.52u w=5u l=0.7u
X115 ESD_RAIL a_1852_148519# VSS VSS nfet_06v0 ad=13.936p pd=54.12u as=13.936p ps=54.12u w=53.6u l=0.7u
X116 a_2245_90628# a_4789_117064# VSS VSS nfet_06v0 ad=1.3p pd=5.52u as=1.3p ps=5.52u w=5u l=0.7u
X117 PAD_P a_84424_91054# VSS ppolyf_u r_width=2u r_length=1u
X118 a_2245_90628# a_4789_117064# ESD_RAIL ESD_RAIL pfet_06v0 ad=1.3p pd=5.52u as=1.3p ps=5.52u w=5u l=0.7u
X119 PAD_P a_68216_96914# VSS ppolyf_u r_width=2u r_length=2.6u
X120 ESD_RAIL a_1005_131545# a_3813_117064# ESD_RAIL pfet_06v0 ad=1.3p pd=5.52u as=1.3p ps=5.52u w=5u l=0.7u
X121 ESD_RAIL a_1852_148519# VSS VSS nfet_06v0 ad=13.936p pd=54.12u as=13.936p ps=54.12u w=53.6u l=0.7u
X122 VSS a_1852_148519# ESD_RAIL VSS nfet_06v0 ad=13.936p pd=54.12u as=13.936p ps=54.12u w=53.6u l=0.7u
X123 VSS a_1852_148519# ESD_RAIL VSS nfet_06v0 ad=13.936p pd=54.12u as=13.936p ps=54.12u w=53.6u l=0.7u
X124 VSS a_2245_90628# ESD_RAIL VSS nfet_06v0 ad=13p pd=50.52u as=13p ps=50.52u w=50u l=0.7u
X125 ESD_RAIL a_1852_148519# VSS VSS nfet_06v0 ad=13.936p pd=54.12u as=23.584p ps=0.10808m w=53.6u l=0.7u
X126 ESD_RAIL a_1852_148519# VSS VSS nfet_06v0 ad=13.936p pd=54.12u as=23.584p ps=0.10808m w=53.6u l=0.7u
X127 ESD_RAIL a_1852_148519# VSS VSS nfet_06v0 ad=13.936p pd=54.12u as=13.936p ps=54.12u w=53.6u l=0.7u
X128 a_2245_90628# a_4789_117064# ESD_RAIL ESD_RAIL pfet_06v0 ad=1.3p pd=5.52u as=1.3p ps=5.52u w=5u l=0.7u
X129 VSS a_1852_148519# ESD_RAIL VSS nfet_06v0 ad=23.584p pd=0.10808m as=13.936p ps=54.12u w=53.6u l=0.7u
X130 a_83356_91054# TERM_TRIM2 TERM_VCM VSS nfet_06v0 ad=5.28p pd=24.88u as=5.28p ps=24.88u w=12u l=0.7u
X131 VSS a_1852_148519# ESD_RAIL VSS nfet_06v0 ad=13.936p pd=54.12u as=13.936p ps=54.12u w=53.6u l=0.7u
X132 VSS a_1852_148519# ESD_RAIL VSS nfet_06v0 ad=13.936p pd=54.12u as=13.936p ps=54.12u w=53.6u l=0.7u
X133 ESD_RAIL a_2245_90628# VSS VSS nfet_06v0 ad=13p pd=50.52u as=13p ps=50.52u w=50u l=0.7u
X134 a_81220_152846# PAD_N VSS ppolyf_u r_width=2u r_length=1u
X135 a_1005_131545# VSS cap_mim_2f0_m4m5_noshield c_width=14u c_length=14u
X136 ESD_RAIL a_2245_90628# VSS VSS nfet_06v0 ad=13p pd=50.52u as=13p ps=50.52u w=50u l=0.7u
X137 ESD_RAIL a_1852_148519# VSS VSS nfet_06v0 ad=13.936p pd=54.12u as=13.936p ps=54.12u w=53.6u l=0.7u
X138 VSS a_1852_148519# ESD_RAIL VSS nfet_06v0 ad=13.936p pd=54.12u as=13.936p ps=54.12u w=53.6u l=0.7u
X139 a_87628_152846# TERM_TRIM3 TERM_VCM VSS nfet_06v0 ad=5.28p pd=24.88u as=5.28p ps=24.88u w=12u l=0.7u
X140 ESD_RAIL a_1852_148519# VSS VSS nfet_06v0 ad=13.936p pd=54.12u as=13.936p ps=54.12u w=53.6u l=0.7u
X141 a_1005_131825# a_13878_132105# ESD_RAIL ppolyf_u r_width=0.8u r_length=63.855u
D7 PAD_P ESD_RAIL diode_pd2nw_06v0 pj=51.8u area=22.5p
X142 VSS a_1852_148519# ESD_RAIL VSS nfet_06v0 ad=23.584p pd=0.10808m as=13.936p ps=54.12u w=53.6u l=0.7u
X143 ESD_RAIL a_2245_90628# VSS VSS nfet_06v0 ad=13p pd=50.52u as=13p ps=50.52u w=50u l=0.7u
X144 ESD_RAIL a_2245_90628# VSS VSS nfet_06v0 ad=13p pd=50.52u as=13p ps=50.52u w=50u l=0.7u
X145 PAD_P a_82288_91054# VSS ppolyf_u r_width=2u r_length=1u
X146 a_2245_90628# a_4789_117064# ESD_RAIL ESD_RAIL pfet_06v0 ad=1.3p pd=5.52u as=1.3p ps=5.52u w=5u l=0.7u
X147 ESD_RAIL a_2245_90628# VSS VSS nfet_06v0 ad=13p pd=50.52u as=13p ps=50.52u w=50u l=0.7u
X148 VSS a_2245_90628# ESD_RAIL VSS nfet_06v0 ad=13p pd=50.52u as=13p ps=50.52u w=50u l=0.7u
X149 VSS a_1852_148519# ESD_RAIL VSS nfet_06v0 ad=13.936p pd=54.12u as=13.936p ps=54.12u w=53.6u l=0.7u
X150 ESD_RAIL a_1852_148519# VSS VSS nfet_06v0 ad=13.936p pd=54.12u as=13.936p ps=54.12u w=53.6u l=0.7u
X151 ESD_RAIL a_1852_148519# VSS VSS nfet_06v0 ad=13.936p pd=54.12u as=13.936p ps=54.12u w=53.6u l=0.7u
X152 VSS a_2245_90628# ESD_RAIL VSS nfet_06v0 ad=13p pd=50.52u as=13p ps=50.52u w=50u l=0.7u
X153 a_2245_90628# a_4789_117064# ESD_RAIL ESD_RAIL pfet_06v0 ad=1.3p pd=5.52u as=1.3p ps=5.52u w=5u l=0.7u
X154 VSS a_1852_148519# ESD_RAIL VSS nfet_06v0 ad=13.936p pd=54.12u as=13.936p ps=54.12u w=53.6u l=0.7u
X155 PAD_P a_89764_91054# VSS ppolyf_u r_width=2u r_length=1u
X156 VSS a_4789_117064# a_2245_90628# VSS nfet_06v0 ad=2.2p pd=10.88u as=1.3p ps=5.52u w=5u l=0.7u
X157 ESD_RAIL a_4789_117064# a_2245_90628# ESD_RAIL pfet_06v0 ad=1.3p pd=5.52u as=1.3p ps=5.52u w=5u l=0.7u
X158 ESD_RAIL a_2245_90628# VSS VSS nfet_06v0 ad=22p pd=0.10088m as=13p ps=50.52u w=50u l=0.7u
D8 VSS PAD_N diode_nd2ps_06v0 pj=51.8u area=22.5p
X159 a_1005_132945# a_13878_133225# ESD_RAIL ppolyf_u r_width=0.8u r_length=63.855u
X160 ESD_RAIL a_1852_148519# VSS VSS nfet_06v0 ad=13.936p pd=54.12u as=13.936p ps=54.12u w=53.6u l=0.7u
X161 ESD_RAIL a_1852_148519# VSS VSS nfet_06v0 ad=13.936p pd=54.12u as=13.936p ps=54.12u w=53.6u l=0.7u
X162 ESD_RAIL a_1852_148519# VSS VSS nfet_06v0 ad=13.936p pd=54.12u as=13.936p ps=54.12u w=53.6u l=0.7u
X163 VSS a_1852_148519# ESD_RAIL VSS nfet_06v0 ad=13.936p pd=54.12u as=13.936p ps=54.12u w=53.6u l=0.7u
X164 ESD_RAIL a_4789_117064# a_2245_90628# ESD_RAIL pfet_06v0 ad=1.3p pd=5.52u as=1.3p ps=5.52u w=5u l=0.7u
X165 ESD_RAIL a_1852_148519# VSS VSS nfet_06v0 ad=13.936p pd=54.12u as=13.936p ps=54.12u w=53.6u l=0.7u
X166 a_2245_90628# a_4789_117064# VSS VSS nfet_06v0 ad=1.3p pd=5.52u as=1.3p ps=5.52u w=5u l=0.7u
X167 a_2245_90628# a_4789_117064# ESD_RAIL ESD_RAIL pfet_06v0 ad=1.3p pd=5.52u as=2.2p ps=10.88u w=5u l=0.7u
X168 a_3813_117064# a_1005_131545# VSS VSS nfet_06v0 ad=2.2p pd=10.88u as=2.2p ps=10.88u w=5u l=0.7u
X169 a_85492_91054# TERM_TRIM2 TERM_VCM VSS nfet_06v0 ad=5.28p pd=24.88u as=5.28p ps=24.88u w=12u l=0.7u
X170 a_92968_152846# TERM_TRIM3 TERM_VCM VSS nfet_06v0 ad=5.28p pd=24.88u as=5.28p ps=24.88u w=12u l=0.7u
X171 PAD_P a_70540_90254# VSS ppolyf_u r_width=2u r_length=2.6u
X172 VSS a_1852_148519# ESD_RAIL VSS nfet_06v0 ad=13.936p pd=54.12u as=13.936p ps=54.12u w=53.6u l=0.7u
X173 VSS a_1852_148519# ESD_RAIL VSS nfet_06v0 ad=13.936p pd=54.12u as=13.936p ps=54.12u w=53.6u l=0.7u
D9 PAD_P ESD_RAIL diode_pd2nw_06v0 pj=51.8u area=22.5p
X174 VSS a_1852_148519# ESD_RAIL VSS nfet_06v0 ad=13.936p pd=54.12u as=13.936p ps=54.12u w=53.6u l=0.7u
X175 VSS a_1852_148519# ESD_RAIL VSS nfet_06v0 ad=13.936p pd=54.12u as=13.936p ps=54.12u w=53.6u l=0.7u
X176 a_74812_152046# PAD_N VSS ppolyf_u r_width=2u r_length=2.6u
X177 ESD_RAIL a_2245_90628# VSS VSS nfet_06v0 ad=13p pd=50.52u as=13p ps=50.52u w=50u l=0.7u
X178 a_2245_90628# a_4789_117064# VSS VSS nfet_06v0 ad=1.3p pd=5.52u as=1.3p ps=5.52u w=5u l=0.7u
X179 VDD w_71178_112088# w_71178_112088# w_71178_112088# pfet_06v0 ad=1.76p pd=8.88u as=1.76p ps=8.88u w=4u l=0.55u
X180 VSS a_3813_117064# a_4789_117064# VSS nfet_06v0 ad=1.3p pd=5.52u as=1.3p ps=5.52u w=5u l=0.7u
X181 a_2245_90628# a_4789_117064# ESD_RAIL ESD_RAIL pfet_06v0 ad=1.3p pd=5.52u as=1.3p ps=5.52u w=5u l=0.7u
X182 ESD_RAIL a_1852_148519# VSS VSS nfet_06v0 ad=13.936p pd=54.12u as=13.936p ps=54.12u w=53.6u l=0.7u
X183 PAD_P a_76948_90254# VSS ppolyf_u r_width=2u r_length=2.6u
X184 VSS a_1852_148519# ESD_RAIL VSS nfet_06v0 ad=13.936p pd=54.12u as=13.936p ps=54.12u w=53.6u l=0.7u
X185 a_70540_152046# TERM_ENABLE TERM_VCM VSS nfet_06v0 ad=8.8p pd=40.88u as=8.8p ps=40.88u w=20u l=0.7u
X186 a_1005_134065# a_13878_134345# ESD_RAIL ppolyf_u r_width=0.8u r_length=63.855u
X187 ESD_RAIL a_2245_90628# VSS VSS nfet_06v0 ad=13p pd=50.52u as=13p ps=50.52u w=50u l=0.7u
X188 ESD_RAIL a_1852_148519# VSS VSS nfet_06v0 ad=13.936p pd=54.12u as=13.936p ps=54.12u w=53.6u l=0.7u
X189 ESD_RAIL a_2245_90628# VSS VSS nfet_06v0 ad=13p pd=50.52u as=13p ps=50.52u w=50u l=0.7u
X190 a_78016_90254# TERM_ENABLE TERM_VCM VSS nfet_06v0 ad=8.8p pd=40.88u as=8.8p ps=40.88u w=20u l=0.7u
X191 VSS a_3813_117064# a_4789_117064# VSS nfet_06v0 ad=1.3p pd=5.52u as=1.3p ps=5.52u w=5u l=0.7u
D10 PAD_P ESD_RAIL diode_pd2nw_06v0 pj=51.8u area=22.5p
X192 PAD_P a_80152_91054# VSS ppolyf_u r_width=2u r_length=1u
X193 VSS a_1852_148519# ESD_RAIL VSS nfet_06v0 ad=13.936p pd=54.12u as=13.936p ps=54.12u w=53.6u l=0.7u
X194 ESD_RAIL a_1852_148519# VSS VSS nfet_06v0 ad=13.936p pd=54.12u as=13.936p ps=54.12u w=53.6u l=0.7u
X195 VSS a_2245_90628# ESD_RAIL VSS nfet_06v0 ad=13p pd=50.52u as=13p ps=50.52u w=50u l=0.7u
X196 RX_P VSS VSS VSS nfet_06v0 ad=1.76p pd=8.88u as=1.76p ps=8.88u w=4u l=0.7u
X197 VSS a_1852_148519# ESD_RAIL VSS nfet_06v0 ad=13.936p pd=54.12u as=13.936p ps=54.12u w=53.6u l=0.7u
X198 a_70540_90254# TERM_ENABLE TERM_VCM VSS nfet_06v0 ad=8.8p pd=40.88u as=8.8p ps=40.88u w=20u l=0.7u
X199 ESD_RAIL a_2245_90628# VSS VSS nfet_06v0 ad=13p pd=50.52u as=13p ps=50.52u w=50u l=0.7u
X200 a_94036_152846# TERM_TRIM3 TERM_VCM VSS nfet_06v0 ad=5.28p pd=24.88u as=5.28p ps=24.88u w=12u l=0.7u
X201 ESD_RAIL a_1852_148519# VSS VSS nfet_06v0 ad=13.936p pd=54.12u as=13.936p ps=54.12u w=53.6u l=0.7u
X202 VSS a_1852_148519# ESD_RAIL VSS nfet_06v0 ad=13.936p pd=54.12u as=13.936p ps=54.12u w=53.6u l=0.7u
D11 VSS PAD_N diode_nd2ps_06v0 pj=51.8u area=22.5p
X203 VSS a_1852_148519# ESD_RAIL VSS nfet_06v0 ad=13.936p pd=54.12u as=13.936p ps=54.12u w=53.6u l=0.7u
X204 a_90832_91054# TERM_TRIM3 TERM_VCM VSS nfet_06v0 ad=5.28p pd=24.88u as=5.28p ps=24.88u w=12u l=0.7u
X205 ESD_RAIL a_1852_148519# VSS VSS nfet_06v0 ad=13.936p pd=54.12u as=13.936p ps=54.12u w=53.6u l=0.7u
X206 a_2245_90628# a_4789_117064# ESD_RAIL ESD_RAIL pfet_06v0 ad=1.3p pd=5.52u as=1.3p ps=5.52u w=5u l=0.7u
X207 a_90832_152846# PAD_N VSS ppolyf_u r_width=2u r_length=1u
X208 VSS a_1852_148519# ESD_RAIL VSS nfet_06v0 ad=23.584p pd=0.10808m as=13.936p ps=54.12u w=53.6u l=0.7u
X209 ESD_RAIL a_2245_90628# VSS VSS nfet_06v0 ad=13p pd=50.52u as=13p ps=50.52u w=50u l=0.7u
X210 VSS a_1852_148519# ESD_RAIL VSS nfet_06v0 ad=13.936p pd=54.12u as=13.936p ps=54.12u w=53.6u l=0.7u
X211 VSS a_1852_148519# ESD_RAIL VSS nfet_06v0 ad=13.936p pd=54.12u as=13.936p ps=54.12u w=53.6u l=0.7u
X212 VSS a_1852_148519# ESD_RAIL VSS nfet_06v0 ad=13.936p pd=54.12u as=13.936p ps=54.12u w=53.6u l=0.7u
X213 VSS a_2245_90628# ESD_RAIL VSS nfet_06v0 ad=13p pd=50.52u as=13p ps=50.52u w=50u l=0.7u
D12 PAD_P ESD_RAIL diode_pd2nw_06v0 pj=51.8u area=22.5p
X214 a_92968_152846# PAD_N VSS ppolyf_u r_width=2u r_length=1u
X215 ESD_RAIL a_2245_90628# VSS VSS nfet_06v0 ad=13p pd=50.52u as=13p ps=50.52u w=50u l=0.7u
X216 VSS a_1852_148519# ESD_RAIL VSS nfet_06v0 ad=23.584p pd=0.10808m as=13.936p ps=54.12u w=53.6u l=0.7u
X217 VSS a_1852_148519# ESD_RAIL VSS nfet_06v0 ad=23.584p pd=0.10808m as=13.936p ps=54.12u w=53.6u l=0.7u
X218 a_84424_152846# PAD_N VSS ppolyf_u r_width=2u r_length=1u
X219 ESD_RAIL a_1852_148519# VSS VSS nfet_06v0 ad=13.936p pd=54.12u as=13.936p ps=54.12u w=53.6u l=0.7u
X220 ESD_RAIL a_1852_148519# VSS VSS nfet_06v0 ad=13.936p pd=54.12u as=13.936p ps=54.12u w=53.6u l=0.7u
X221 VSS a_1852_148519# ESD_RAIL VSS nfet_06v0 ad=13.936p pd=54.12u as=13.936p ps=54.12u w=53.6u l=0.7u
X222 VSS a_2245_90628# ESD_RAIL VSS nfet_06v0 ad=13p pd=50.52u as=13p ps=50.52u w=50u l=0.7u
X223 VSS a_1852_148519# ESD_RAIL VSS nfet_06v0 ad=13.936p pd=54.12u as=13.936p ps=54.12u w=53.6u l=0.7u
X224 RX_P PAD_P cap_mim_2f0_m4m5_noshield c_width=35u c_length=35u
X225 ESD_RAIL a_1852_148519# VSS VSS nfet_06v0 ad=13.936p pd=54.12u as=13.936p ps=54.12u w=53.6u l=0.7u
X226 ESD_RAIL a_1852_148519# VSS VSS nfet_06v0 ad=13.936p pd=54.12u as=13.936p ps=54.12u w=53.6u l=0.7u
X227 VSS a_1852_148519# ESD_RAIL VSS nfet_06v0 ad=13.936p pd=54.12u as=13.936p ps=54.12u w=53.6u l=0.7u
X228 ESD_RAIL a_2245_90628# VSS VSS nfet_06v0 ad=13p pd=50.52u as=13p ps=50.52u w=50u l=0.7u
X229 VSS a_1852_148519# ESD_RAIL VSS nfet_06v0 ad=13.936p pd=54.12u as=13.936p ps=54.12u w=53.6u l=0.7u
X230 RX_P VDD VDD VDD pfet_06v0 ad=1.76p pd=8.88u as=1.76p ps=8.88u w=4u l=0.55u
X231 a_76948_90254# TERM_ENABLE TERM_VCM VSS nfet_06v0 ad=8.8p pd=40.88u as=8.8p ps=40.88u w=20u l=0.7u
D13 PAD_N ESD_RAIL diode_pd2nw_06v0 pj=51.8u area=22.5p
X232 ESD_RAIL a_2245_90628# VSS VSS nfet_06v0 ad=13p pd=50.52u as=13p ps=50.52u w=50u l=0.7u
X233 ESD_RAIL a_2245_90628# VSS VSS nfet_06v0 ad=13p pd=50.52u as=13p ps=50.52u w=50u l=0.7u
D14 VSS ESD_RAIL diode_nd2ps_06v0 pj=82u area=40p
X234 ESD_RAIL a_1852_148519# VSS VSS nfet_06v0 ad=13.936p pd=54.12u as=13.936p ps=54.12u w=53.6u l=0.7u
X235 PAD_P a_72676_90254# VSS ppolyf_u r_width=2u r_length=2.6u
X236 a_4789_117064# a_3813_117064# VSS VSS nfet_06v0 ad=1.3p pd=5.52u as=2.2p ps=10.88u w=5u l=0.7u
X237 ESD_RAIL a_1852_148519# VSS VSS nfet_06v0 ad=13.936p pd=54.12u as=13.936p ps=54.12u w=53.6u l=0.7u
X238 ESD_RAIL a_2245_90628# VSS VSS nfet_06v0 ad=13p pd=50.52u as=13p ps=50.52u w=50u l=0.7u
X239 a_71608_90254# TERM_ENABLE TERM_VCM VSS nfet_06v0 ad=8.8p pd=40.88u as=8.8p ps=40.88u w=20u l=0.7u
D15 VSS ESD_RAIL diode_nd2ps_06v0 pj=82u area=40p
X240 VSS a_2245_90628# ESD_RAIL VSS nfet_06v0 ad=13p pd=50.52u as=13p ps=50.52u w=50u l=0.7u
X241 VSS a_1852_148519# ESD_RAIL VSS nfet_06v0 ad=13.936p pd=54.12u as=13.936p ps=54.12u w=53.6u l=0.7u
X242 a_68216_96914# TERM_ENABLE TERM_VCM VSS nfet_06v0 ad=8.8p pd=40.88u as=8.8p ps=40.88u w=20u l=0.7u
D16 PAD_N ESD_RAIL diode_pd2nw_06v0 pj=51.8u area=22.5p
X243 ESD_RAIL a_1852_148519# cap_mim_2f0_m4m5_noshield c_width=90u c_length=90u
X244 a_1005_131825# a_13878_131545# ESD_RAIL ppolyf_u r_width=0.8u r_length=63.855u
X245 ESD_RAIL a_1852_148519# VSS VSS nfet_06v0 ad=13.936p pd=54.12u as=13.936p ps=54.12u w=53.6u l=0.7u
X246 ESD_RAIL a_1852_148519# VSS VSS nfet_06v0 ad=13.936p pd=54.12u as=13.936p ps=54.12u w=53.6u l=0.7u
X247 VSS a_1852_148519# ESD_RAIL VSS nfet_06v0 ad=13.936p pd=54.12u as=13.936p ps=54.12u w=53.6u l=0.7u
X248 ESD_RAIL VSS cap_mim_2f0_m4m5_noshield c_width=31.6u c_length=31.6u
X249 a_70540_152046# PAD_N VSS ppolyf_u r_width=2u r_length=2.6u
X250 a_76948_152046# TERM_ENABLE TERM_VCM VSS nfet_06v0 ad=8.8p pd=40.88u as=8.8p ps=40.88u w=20u l=0.7u
X251 ESD_RAIL a_1852_148519# VSS VSS nfet_06v0 ad=13.936p pd=54.12u as=13.936p ps=54.12u w=53.6u l=0.7u
X252 VSS a_2245_90628# ESD_RAIL VSS nfet_06v0 ad=13p pd=50.52u as=22p ps=0.10088m w=50u l=0.7u
X253 a_86560_91054# TERM_TRIM3 TERM_VCM VSS nfet_06v0 ad=5.28p pd=24.88u as=5.28p ps=24.88u w=12u l=0.7u
D17 VSS PAD_P diode_nd2ps_06v0 pj=51.8u area=22.5p
X254 a_86560_152846# TERM_TRIM3 TERM_VCM VSS nfet_06v0 ad=5.28p pd=24.88u as=5.28p ps=24.88u w=12u l=0.7u
X255 VSS a_2245_90628# ESD_RAIL VSS nfet_06v0 ad=13p pd=50.52u as=22p ps=0.10088m w=50u l=0.7u
X256 ESD_RAIL a_4789_117064# a_2245_90628# ESD_RAIL pfet_06v0 ad=1.3p pd=5.52u as=1.3p ps=5.52u w=5u l=0.7u
X257 a_81220_91054# TERM_TRIM1 TERM_VCM VSS nfet_06v0 ad=5.28p pd=24.88u as=5.28p ps=24.88u w=12u l=0.7u
X258 VSS a_1852_148519# ESD_RAIL VSS nfet_06v0 ad=13.936p pd=54.12u as=13.936p ps=54.12u w=53.6u l=0.7u
X259 ESD_RAIL a_1852_148519# VSS VSS nfet_06v0 ad=13.936p pd=54.12u as=13.936p ps=54.12u w=53.6u l=0.7u
X260 VBIAS RX_P VSS ppolyf_u_1k r_width=1u r_length=40u
X261 ESD_RAIL a_1852_148519# VSS VSS nfet_06v0 ad=13.936p pd=54.12u as=13.936p ps=54.12u w=53.6u l=0.7u
X262 VSS a_1852_148519# ESD_RAIL VSS nfet_06v0 ad=13.936p pd=54.12u as=13.936p ps=54.12u w=53.6u l=0.7u
X263 VSS a_2245_90628# ESD_RAIL VSS nfet_06v0 ad=13p pd=50.52u as=13p ps=50.52u w=50u l=0.7u
X264 ESD_RAIL a_4789_117064# a_2245_90628# ESD_RAIL pfet_06v0 ad=1.3p pd=5.52u as=1.3p ps=5.52u w=5u l=0.7u
X265 ESD_RAIL a_2245_90628# VSS VSS nfet_06v0 ad=13p pd=50.52u as=13p ps=50.52u w=50u l=0.7u
X266 a_1005_132945# a_13878_132665# ESD_RAIL ppolyf_u r_width=0.8u r_length=63.855u
X267 ESD_RAIL a_1852_148519# VSS VSS nfet_06v0 ad=13.936p pd=54.12u as=13.936p ps=54.12u w=53.6u l=0.7u
X268 ESD_RAIL a_2245_90628# VSS VSS nfet_06v0 ad=13p pd=50.52u as=13p ps=50.52u w=50u l=0.7u
X269 ESD_RAIL a_1852_148519# VSS VSS nfet_06v0 ad=13.936p pd=54.12u as=13.936p ps=54.12u w=53.6u l=0.7u
D18 PAD_N ESD_RAIL diode_pd2nw_06v0 pj=51.8u area=22.5p
X270 a_89764_152846# PAD_N VSS ppolyf_u r_width=2u r_length=1u
X271 a_78016_152046# TERM_ENABLE TERM_VCM VSS nfet_06v0 ad=8.8p pd=40.88u as=8.8p ps=40.88u w=20u l=0.7u
X272 VSS a_1852_148519# ESD_RAIL VSS nfet_06v0 ad=13.936p pd=54.12u as=13.936p ps=54.12u w=53.6u l=0.7u
X273 ESD_RAIL a_1852_148519# VSS VSS nfet_06v0 ad=13.936p pd=54.12u as=13.936p ps=54.12u w=53.6u l=0.7u
X274 ESD_RAIL a_1852_148519# VSS VSS nfet_06v0 ad=13.936p pd=54.12u as=13.936p ps=54.12u w=53.6u l=0.7u
X275 VSS a_1852_148519# ESD_RAIL VSS nfet_06v0 ad=23.584p pd=0.10808m as=13.936p ps=54.12u w=53.6u l=0.7u
X276 ESD_RAIL a_1852_148519# VSS VSS nfet_06v0 ad=13.936p pd=54.12u as=13.936p ps=54.12u w=53.6u l=0.7u
X277 VSS a_2245_90628# ESD_RAIL VSS nfet_06v0 ad=13p pd=50.52u as=13p ps=50.52u w=50u l=0.7u
X278 VSS a_1852_148519# ESD_RAIL VSS nfet_06v0 ad=13.936p pd=54.12u as=13.936p ps=54.12u w=53.6u l=0.7u
X279 VSS a_1852_148519# ESD_RAIL VSS nfet_06v0 ad=13.936p pd=54.12u as=13.936p ps=54.12u w=53.6u l=0.7u
X280 VSS a_1852_148519# ESD_RAIL VSS nfet_06v0 ad=13.936p pd=54.12u as=13.936p ps=54.12u w=53.6u l=0.7u
X281 VSS a_1852_148519# ESD_RAIL VSS nfet_06v0 ad=13.936p pd=54.12u as=13.936p ps=54.12u w=53.6u l=0.7u
X282 VSS a_1852_148519# ESD_RAIL VSS nfet_06v0 ad=13.936p pd=54.12u as=13.936p ps=54.12u w=53.6u l=0.7u
X283 ESD_RAIL a_1852_148519# VSS VSS nfet_06v0 ad=13.936p pd=54.12u as=13.936p ps=54.12u w=53.6u l=0.7u
X284 a_3813_117064# a_1005_131545# ESD_RAIL ESD_RAIL pfet_06v0 ad=1.3p pd=5.52u as=1.3p ps=5.52u w=5u l=0.7u
X285 a_85492_152846# TERM_TRIM2 TERM_VCM VSS nfet_06v0 ad=5.28p pd=24.88u as=5.28p ps=24.88u w=12u l=0.7u
X286 a_91900_91054# TERM_TRIM3 TERM_VCM VSS nfet_06v0 ad=5.28p pd=24.88u as=5.28p ps=24.88u w=12u l=0.7u
X287 a_83356_152846# TERM_TRIM2 TERM_VCM VSS nfet_06v0 ad=5.28p pd=24.88u as=5.28p ps=24.88u w=12u l=0.7u
X288 VSS a_1852_148519# ESD_RAIL VSS nfet_06v0 ad=23.584p pd=0.10808m as=13.936p ps=54.12u w=53.6u l=0.7u
D19 PAD_N ESD_RAIL diode_pd2nw_06v0 pj=51.8u area=22.5p
X289 VSS ESD_RAIL VSS ppolyf_u_1k_6p0 r_width=1u r_length=9.98874m
X290 ESD_RAIL a_1852_148519# VSS VSS nfet_06v0 ad=13.936p pd=54.12u as=13.936p ps=54.12u w=53.6u l=0.7u
X291 ESD_RAIL a_1852_148519# VSS VSS nfet_06v0 ad=13.936p pd=54.12u as=13.936p ps=54.12u w=53.6u l=0.7u
X292 ESD_RAIL a_1852_148519# VSS VSS nfet_06v0 ad=13.936p pd=54.12u as=23.584p ps=0.10808m w=53.6u l=0.7u
X293 a_4789_117064# a_3813_117064# ESD_RAIL ESD_RAIL pfet_06v0 ad=2.2p pd=10.88u as=1.3p ps=5.52u w=5u l=0.7u
X294 ESD_RAIL a_1852_148519# VSS VSS nfet_06v0 ad=13.936p pd=54.12u as=23.584p ps=0.10808m w=53.6u l=0.7u
X295 ESD_RAIL a_2245_90628# VSS VSS nfet_06v0 ad=13p pd=50.52u as=13p ps=50.52u w=50u l=0.7u
X296 VSS a_1852_148519# ESD_RAIL VSS nfet_06v0 ad=13.936p pd=54.12u as=13.936p ps=54.12u w=53.6u l=0.7u
X297 ESD_RAIL a_1852_148519# VSS VSS nfet_06v0 ad=13.936p pd=54.12u as=13.936p ps=54.12u w=53.6u l=0.7u
X298 ESD_RAIL a_2245_90628# VSS VSS nfet_06v0 ad=13p pd=50.52u as=13p ps=50.52u w=50u l=0.7u
X299 ESD_RAIL a_1852_148519# VSS VSS nfet_06v0 ad=13.936p pd=54.12u as=13.936p ps=54.12u w=53.6u l=0.7u
X300 VSS a_1852_148519# ESD_RAIL VSS nfet_06v0 ad=13.936p pd=54.12u as=13.936p ps=54.12u w=53.6u l=0.7u
X301 a_82288_152846# PAD_N VSS ppolyf_u r_width=2u r_length=1u
X302 a_72676_152046# PAD_N VSS ppolyf_u r_width=2u r_length=2.6u
X303 RX_N PAD_N cap_mim_2f0_m4m5_noshield c_width=35u c_length=35u
X304 PAD_P a_90832_91054# VSS ppolyf_u r_width=2u r_length=1u
X305 a_2245_90628# a_4789_117064# ESD_RAIL ESD_RAIL pfet_06v0 ad=1.3p pd=5.52u as=1.3p ps=5.52u w=5u l=0.7u
X306 VSS a_1852_148519# ESD_RAIL VSS nfet_06v0 ad=13.936p pd=54.12u as=13.936p ps=54.12u w=53.6u l=0.7u
X307 VSS a_2245_90628# ESD_RAIL VSS nfet_06v0 ad=13p pd=50.52u as=13p ps=50.52u w=50u l=0.7u
X308 ESD_RAIL a_2245_90628# VSS VSS nfet_06v0 ad=13p pd=50.52u as=13p ps=50.52u w=50u l=0.7u
X309 VSS a_1852_148519# ESD_RAIL VSS nfet_06v0 ad=13.936p pd=54.12u as=13.936p ps=54.12u w=53.6u l=0.7u
X310 a_1005_134065# a_13878_133785# ESD_RAIL ppolyf_u r_width=0.8u r_length=63.855u
X311 a_84424_152846# TERM_TRIM2 TERM_VCM VSS nfet_06v0 ad=5.28p pd=24.88u as=5.28p ps=24.88u w=12u l=0.7u
X312 ESD_RAIL a_1852_148519# VSS VSS nfet_06v0 ad=13.936p pd=54.12u as=13.936p ps=54.12u w=53.6u l=0.7u
X313 ESD_RAIL a_1852_148519# VSS VSS nfet_06v0 ad=13.936p pd=54.12u as=13.936p ps=54.12u w=53.6u l=0.7u
X314 a_87628_91054# TERM_TRIM3 TERM_VCM VSS nfet_06v0 ad=5.28p pd=24.88u as=5.28p ps=24.88u w=12u l=0.7u
X315 ESD_RAIL a_1852_148519# VSS VSS nfet_06v0 ad=13.936p pd=54.12u as=13.936p ps=54.12u w=53.6u l=0.7u
X316 VSS a_2245_90628# ESD_RAIL VSS nfet_06v0 ad=13p pd=50.52u as=13p ps=50.52u w=50u l=0.7u
X317 a_82288_152846# TERM_TRIM2 TERM_VCM VSS nfet_06v0 ad=5.28p pd=24.88u as=5.28p ps=24.88u w=12u l=0.7u
X318 VSS a_2245_90628# ESD_RAIL VSS nfet_06v0 ad=13p pd=50.52u as=13p ps=50.52u w=50u l=0.7u
X319 ESD_RAIL a_4789_117064# a_2245_90628# ESD_RAIL pfet_06v0 ad=1.3p pd=5.52u as=1.3p ps=5.52u w=5u l=0.7u
X320 ESD_RAIL a_1852_148519# VSS VSS nfet_06v0 ad=13.936p pd=54.12u as=13.936p ps=54.12u w=53.6u l=0.7u
X321 PAD_P a_92968_91054# VSS ppolyf_u r_width=2u r_length=1u
X322 ESD_RAIL a_1852_148519# VSS VSS nfet_06v0 ad=13.936p pd=54.12u as=13.936p ps=54.12u w=53.6u l=0.7u
X323 VSS a_2245_90628# ESD_RAIL VSS nfet_06v0 ad=13p pd=50.52u as=13p ps=50.52u w=50u l=0.7u
X324 ESD_RAIL a_1852_148519# cap_mim_2f0_m4m5_noshield c_width=90u c_length=90u
D20 VSS ESD_RAIL diode_nd2ps_06v0 pj=82u area=40p
X325 a_80152_91054# TERM_TRIM1 TERM_VCM VSS nfet_06v0 ad=5.28p pd=24.88u as=5.28p ps=24.88u w=12u l=0.7u
X326 PAD_P a_69448_96914# VSS ppolyf_u r_width=2u r_length=2.6u
X327 ESD_RAIL a_3813_117064# a_4789_117064# ESD_RAIL pfet_06v0 ad=1.3p pd=5.52u as=1.3p ps=5.52u w=5u l=0.7u
X328 VSS a_1852_148519# ESD_RAIL VSS nfet_06v0 ad=13.936p pd=54.12u as=13.936p ps=54.12u w=53.6u l=0.7u
X329 VSS a_1852_148519# ESD_RAIL VSS nfet_06v0 ad=13.936p pd=54.12u as=13.936p ps=54.12u w=53.6u l=0.7u
X330 VSS a_1852_148519# ESD_RAIL VSS nfet_06v0 ad=13.936p pd=54.12u as=13.936p ps=54.12u w=53.6u l=0.7u
X331 ESD_RAIL a_1852_148519# VSS VSS nfet_06v0 ad=13.936p pd=54.12u as=13.936p ps=54.12u w=53.6u l=0.7u
X332 a_2245_90628# a_4789_117064# ESD_RAIL ESD_RAIL pfet_06v0 ad=1.3p pd=5.52u as=1.3p ps=5.52u w=5u l=0.7u
X333 ESD_RAIL a_1852_148519# VSS VSS nfet_06v0 ad=13.936p pd=54.12u as=13.936p ps=54.12u w=53.6u l=0.7u
X334 VSS a_2245_90628# ESD_RAIL VSS nfet_06v0 ad=13p pd=50.52u as=13p ps=50.52u w=50u l=0.7u
X335 VSS a_1852_148519# ESD_RAIL VSS nfet_06v0 ad=13.936p pd=54.12u as=13.936p ps=54.12u w=53.6u l=0.7u
X336 VSS a_1852_148519# ESD_RAIL VSS nfet_06v0 ad=13.936p pd=54.12u as=13.936p ps=54.12u w=53.6u l=0.7u
X337 VSS a_1852_148519# ESD_RAIL VSS nfet_06v0 ad=13.936p pd=54.12u as=13.936p ps=54.12u w=53.6u l=0.7u
X338 VSS a_1852_148519# ESD_RAIL VSS nfet_06v0 ad=13.936p pd=54.12u as=13.936p ps=54.12u w=53.6u l=0.7u
X339 a_3813_117064# a_1005_131545# ESD_RAIL ESD_RAIL pfet_06v0 ad=1.3p pd=5.52u as=2.2p ps=10.88u w=5u l=0.7u
X340 ESD_RAIL a_1852_148519# VSS VSS nfet_06v0 ad=13.936p pd=54.12u as=13.936p ps=54.12u w=53.6u l=0.7u
X341 ESD_RAIL a_1852_148519# VSS VSS nfet_06v0 ad=13.936p pd=54.12u as=23.584p ps=0.10808m w=53.6u l=0.7u
X342 ESD_RAIL a_2245_90628# VSS VSS nfet_06v0 ad=22p pd=0.10088m as=13p ps=50.52u w=50u l=0.7u
X343 ESD_RAIL a_1852_148519# VSS VSS nfet_06v0 ad=13.936p pd=54.12u as=13.936p ps=54.12u w=53.6u l=0.7u
X344 a_72676_90254# TERM_ENABLE TERM_VCM VSS nfet_06v0 ad=8.8p pd=40.88u as=8.8p ps=40.88u w=20u l=0.7u
X345 ESD_RAIL a_2245_90628# VSS VSS nfet_06v0 ad=13p pd=50.52u as=13p ps=50.52u w=50u l=0.7u
X346 ESD_RAIL a_2245_90628# VSS VSS nfet_06v0 ad=13p pd=50.52u as=13p ps=50.52u w=50u l=0.7u
X347 VSS a_1852_148519# ESD_RAIL VSS nfet_06v0 ad=13.936p pd=54.12u as=13.936p ps=54.12u w=53.6u l=0.7u
X348 VSS a_1852_148519# ESD_RAIL VSS nfet_06v0 ad=23.584p pd=0.10808m as=13.936p ps=54.12u w=53.6u l=0.7u
X349 a_91900_152846# TERM_TRIM3 TERM_VCM VSS nfet_06v0 ad=5.28p pd=24.88u as=5.28p ps=24.88u w=12u l=0.7u
X350 a_4789_117064# a_3813_117064# ESD_RAIL ESD_RAIL pfet_06v0 ad=1.3p pd=5.52u as=1.3p ps=5.52u w=5u l=0.7u
X351 ESD_RAIL a_1852_148519# VSS VSS nfet_06v0 ad=13.936p pd=54.12u as=13.936p ps=54.12u w=53.6u l=0.7u
X352 a_85492_152846# PAD_N VSS ppolyf_u r_width=2u r_length=1u
X353 a_69448_96914# TERM_ENABLE TERM_VCM VSS nfet_06v0 ad=8.8p pd=40.88u as=8.8p ps=40.88u w=20u l=0.7u
X354 VSS a_1852_148519# ESD_RAIL VSS nfet_06v0 ad=13.936p pd=54.12u as=13.936p ps=54.12u w=53.6u l=0.7u
X355 VSS a_1852_148519# ESD_RAIL VSS nfet_06v0 ad=13.936p pd=54.12u as=13.936p ps=54.12u w=53.6u l=0.7u
X356 PAD_P a_83356_91054# VSS ppolyf_u r_width=2u r_length=1u
X357 ESD_RAIL a_1852_148519# VSS VSS nfet_06v0 ad=13.936p pd=54.12u as=13.936p ps=54.12u w=53.6u l=0.7u
X358 ESD_RAIL a_1852_148519# VSS VSS nfet_06v0 ad=13.936p pd=54.12u as=13.936p ps=54.12u w=53.6u l=0.7u
X359 ESD_RAIL a_1852_148519# VSS VSS nfet_06v0 ad=13.936p pd=54.12u as=13.936p ps=54.12u w=53.6u l=0.7u
X360 ESD_RAIL a_1852_148519# VSS VSS nfet_06v0 ad=13.936p pd=54.12u as=13.936p ps=54.12u w=53.6u l=0.7u
X361 VSS a_2245_90628# ESD_RAIL VSS nfet_06v0 ad=13p pd=50.52u as=22p ps=0.10088m w=50u l=0.7u
X362 VSS a_2245_90628# ESD_RAIL VSS nfet_06v0 ad=13p pd=50.52u as=13p ps=50.52u w=50u l=0.7u
D21 PAD_P ESD_RAIL diode_pd2nw_06v0 pj=51.8u area=22.5p
X363 ESD_RAIL a_1852_148519# VSS VSS nfet_06v0 ad=13.936p pd=54.12u as=13.936p ps=54.12u w=53.6u l=0.7u
X364 VSS a_1852_148519# ESD_RAIL VSS nfet_06v0 ad=13.936p pd=54.12u as=13.936p ps=54.12u w=53.6u l=0.7u
X365 VSS a_2245_90628# ESD_RAIL VSS nfet_06v0 ad=13p pd=50.52u as=13p ps=50.52u w=50u l=0.7u
X366 VSS a_2245_90628# ESD_RAIL VSS nfet_06v0 ad=13p pd=50.52u as=13p ps=50.52u w=50u l=0.7u
X367 PAD_P a_74812_90254# VSS ppolyf_u r_width=2u r_length=2.6u
X368 a_1852_148519# VSS VSS ppolyf_u_1k_6p0 r_width=1u r_length=6u
X369 ESD_RAIL a_1852_148519# VSS VSS nfet_06v0 ad=13.936p pd=54.12u as=13.936p ps=54.12u w=53.6u l=0.7u
X370 VSS a_1852_148519# ESD_RAIL VSS nfet_06v0 ad=13.936p pd=54.12u as=13.936p ps=54.12u w=53.6u l=0.7u
D22 PAD_P ESD_RAIL diode_pd2nw_06v0 pj=51.8u area=22.5p
X371 VSS a_1852_148519# ESD_RAIL VSS nfet_06v0 ad=13.936p pd=54.12u as=13.936p ps=54.12u w=53.6u l=0.7u
X372 VSS a_1852_148519# ESD_RAIL VSS nfet_06v0 ad=23.584p pd=0.10808m as=13.936p ps=54.12u w=53.6u l=0.7u
X373 VDD w_71178_112088# w_71178_112088# w_71178_112088# pfet_06v0 ad=1.76p pd=8.88u as=1.76p ps=8.88u w=4u l=0.55u
X374 VSS a_2245_90628# ESD_RAIL VSS nfet_06v0 ad=13p pd=50.52u as=13p ps=50.52u w=50u l=0.7u
X375 a_90832_152846# TERM_TRIM3 TERM_VCM VSS nfet_06v0 ad=5.28p pd=24.88u as=5.28p ps=24.88u w=12u l=0.7u
X376 VSS a_1852_148519# ESD_RAIL VSS nfet_06v0 ad=13.936p pd=54.12u as=13.936p ps=54.12u w=53.6u l=0.7u
D23 VSS PAD_P diode_nd2ps_06v0 pj=51.8u area=22.5p
X377 a_79084_152846# PAD_N VSS ppolyf_u r_width=2u r_length=1u
X378 ESD_RAIL a_1852_148519# VSS VSS nfet_06v0 ad=13.936p pd=54.12u as=23.584p ps=0.10808m w=53.6u l=0.7u
X379 VSS a_1852_148519# ESD_RAIL VSS nfet_06v0 ad=13.936p pd=54.12u as=13.936p ps=54.12u w=53.6u l=0.7u
X380 ESD_RAIL a_2245_90628# VSS VSS nfet_06v0 ad=13p pd=50.52u as=13p ps=50.52u w=50u l=0.7u
X381 ESD_RAIL a_2245_90628# VSS VSS nfet_06v0 ad=13p pd=50.52u as=13p ps=50.52u w=50u l=0.7u
X382 a_68216_149284# PAD_N VSS ppolyf_u r_width=2u r_length=2.6u
X383 ESD_RAIL a_1852_148519# VSS VSS nfet_06v0 ad=13.936p pd=54.12u as=13.936p ps=54.12u w=53.6u l=0.7u
X384 a_74812_90254# TERM_ENABLE TERM_VCM VSS nfet_06v0 ad=8.8p pd=40.88u as=8.8p ps=40.88u w=20u l=0.7u
X385 VSS a_3813_117064# a_4789_117064# VSS nfet_06v0 ad=1.3p pd=5.52u as=1.3p ps=5.52u w=5u l=0.7u
X386 ESD_RAIL a_1852_148519# VSS VSS nfet_06v0 ad=13.936p pd=54.12u as=13.936p ps=54.12u w=53.6u l=0.7u
X387 PAD_P a_81220_91054# VSS ppolyf_u r_width=2u r_length=1u
X388 a_69448_149284# TERM_ENABLE TERM_VCM VSS nfet_06v0 ad=8.8p pd=40.88u as=8.8p ps=40.88u w=20u l=0.7u
X389 VSS a_1852_148519# ESD_RAIL VSS nfet_06v0 ad=13.936p pd=54.12u as=13.936p ps=54.12u w=53.6u l=0.7u
X390 RX_N VSS VSS VSS nfet_06v0 ad=1.76p pd=8.88u as=1.76p ps=8.88u w=4u l=0.7u
X391 VSS a_2245_90628# ESD_RAIL VSS nfet_06v0 ad=13p pd=50.52u as=13p ps=50.52u w=50u l=0.7u
X392 a_71608_152046# PAD_N VSS ppolyf_u r_width=2u r_length=2.6u
X393 ESD_RAIL a_1852_148519# VSS VSS nfet_06v0 ad=13.936p pd=54.12u as=23.584p ps=0.10808m w=53.6u l=0.7u
X394 ESD_RAIL a_1852_148519# VSS VSS nfet_06v0 ad=13.936p pd=54.12u as=13.936p ps=54.12u w=53.6u l=0.7u
X395 VSS a_4789_117064# a_2245_90628# VSS nfet_06v0 ad=1.3p pd=5.52u as=1.3p ps=5.52u w=5u l=0.7u
X396 PAD_P a_88696_91054# VSS ppolyf_u r_width=2u r_length=1u
X397 VSS a_1852_148519# ESD_RAIL VSS nfet_06v0 ad=13.936p pd=54.12u as=13.936p ps=54.12u w=53.6u l=0.7u
X398 VSS a_1852_148519# ESD_RAIL VSS nfet_06v0 ad=13.936p pd=54.12u as=13.936p ps=54.12u w=53.6u l=0.7u
X399 VSS a_4789_117064# a_2245_90628# VSS nfet_06v0 ad=1.3p pd=5.52u as=1.3p ps=5.52u w=5u l=0.7u
X400 VSS a_1852_148519# ESD_RAIL VSS nfet_06v0 ad=13.936p pd=54.12u as=13.936p ps=54.12u w=53.6u l=0.7u
X401 ESD_RAIL a_4789_117064# a_2245_90628# ESD_RAIL pfet_06v0 ad=1.3p pd=5.52u as=1.3p ps=5.52u w=5u l=0.7u
X402 a_94036_152846# PAD_N VSS ppolyf_u r_width=2u r_length=1u
X403 ESD_RAIL a_1852_148519# VSS VSS nfet_06v0 ad=13.936p pd=54.12u as=13.936p ps=54.12u w=53.6u l=0.7u
X404 VSS a_1852_148519# ESD_RAIL VSS nfet_06v0 ad=23.584p pd=0.10808m as=13.936p ps=54.12u w=53.6u l=0.7u
X405 a_1005_131545# a_13878_131545# ESD_RAIL ppolyf_u r_width=0.8u r_length=63.855u
X406 VSS a_2245_90628# ESD_RAIL VSS nfet_06v0 ad=13p pd=50.52u as=13p ps=50.52u w=50u l=0.7u
X407 VSS a_2245_90628# ESD_RAIL VSS nfet_06v0 ad=13p pd=50.52u as=13p ps=50.52u w=50u l=0.7u
X408 ESD_RAIL a_1852_148519# VSS VSS nfet_06v0 ad=13.936p pd=54.12u as=13.936p ps=54.12u w=53.6u l=0.7u
X409 VSS a_1852_148519# ESD_RAIL VSS nfet_06v0 ad=13.936p pd=54.12u as=13.936p ps=54.12u w=53.6u l=0.7u
X410 VSS a_1852_148519# ESD_RAIL VSS nfet_06v0 ad=13.936p pd=54.12u as=13.936p ps=54.12u w=53.6u l=0.7u
X411 ESD_RAIL a_1852_148519# VSS VSS nfet_06v0 ad=13.936p pd=54.12u as=23.584p ps=0.10808m w=53.6u l=0.7u
X412 ESD_RAIL a_1852_148519# VSS VSS nfet_06v0 ad=13.936p pd=54.12u as=23.584p ps=0.10808m w=53.6u l=0.7u
X413 ESD_RAIL a_2245_90628# VSS VSS nfet_06v0 ad=13p pd=50.52u as=13p ps=50.52u w=50u l=0.7u
X414 a_4789_117064# a_3813_117064# VSS VSS nfet_06v0 ad=1.3p pd=5.52u as=1.3p ps=5.52u w=5u l=0.7u
X415 ESD_RAIL a_1852_148519# VSS VSS nfet_06v0 ad=13.936p pd=54.12u as=13.936p ps=54.12u w=53.6u l=0.7u
X416 VSS a_1852_148519# ESD_RAIL VSS nfet_06v0 ad=13.936p pd=54.12u as=13.936p ps=54.12u w=53.6u l=0.7u
D24 PAD_P ESD_RAIL diode_pd2nw_06v0 pj=51.8u area=22.5p
X417 VSS a_1852_148519# ESD_RAIL VSS nfet_06v0 ad=13.936p pd=54.12u as=13.936p ps=54.12u w=53.6u l=0.7u
X418 a_2245_90628# a_4789_117064# ESD_RAIL ESD_RAIL pfet_06v0 ad=1.3p pd=5.52u as=1.3p ps=5.52u w=5u l=0.7u
X419 a_68216_149284# TERM_ENABLE TERM_VCM VSS nfet_06v0 ad=8.8p pd=40.88u as=8.8p ps=40.88u w=20u l=0.7u
X420 VSS a_1852_148519# ESD_RAIL VSS nfet_06v0 ad=13.936p pd=54.12u as=13.936p ps=54.12u w=53.6u l=0.7u
X421 ESD_RAIL a_1852_148519# VSS VSS nfet_06v0 ad=13.936p pd=54.12u as=13.936p ps=54.12u w=53.6u l=0.7u
X422 ESD_RAIL a_1852_148519# VSS VSS nfet_06v0 ad=13.936p pd=54.12u as=13.936p ps=54.12u w=53.6u l=0.7u
X423 VSS a_1852_148519# ESD_RAIL VSS nfet_06v0 ad=13.936p pd=54.12u as=13.936p ps=54.12u w=53.6u l=0.7u
X424 a_88696_91054# TERM_TRIM3 TERM_VCM VSS nfet_06v0 ad=5.28p pd=24.88u as=5.28p ps=24.88u w=12u l=0.7u
X425 a_1005_132385# a_13878_132665# ESD_RAIL ppolyf_u r_width=0.8u r_length=63.855u
X426 ESD_RAIL a_2245_90628# VSS VSS nfet_06v0 ad=13p pd=50.52u as=13p ps=50.52u w=50u l=0.7u
X427 ESD_RAIL a_1852_148519# VSS VSS nfet_06v0 ad=13.936p pd=54.12u as=23.584p ps=0.10808m w=53.6u l=0.7u
X428 ESD_RAIL a_1852_148519# VSS VSS nfet_06v0 ad=13.936p pd=54.12u as=13.936p ps=54.12u w=53.6u l=0.7u
D25 VSS PAD_N diode_nd2ps_06v0 pj=51.8u area=22.5p
X429 VSS a_1852_148519# ESD_RAIL VSS nfet_06v0 ad=23.584p pd=0.10808m as=13.936p ps=54.12u w=53.6u l=0.7u
X430 VSS a_2245_90628# ESD_RAIL VSS nfet_06v0 ad=13p pd=50.52u as=13p ps=50.52u w=50u l=0.7u
X431 a_87628_152846# PAD_N VSS ppolyf_u r_width=2u r_length=1u
X432 PAD_P a_79084_91054# VSS ppolyf_u r_width=2u r_length=1u
X433 a_86560_152846# PAD_N VSS ppolyf_u r_width=2u r_length=1u
X434 VSS a_2245_90628# ESD_RAIL VSS nfet_06v0 ad=13p pd=50.52u as=13p ps=50.52u w=50u l=0.7u
X435 a_76948_152046# PAD_N VSS ppolyf_u r_width=2u r_length=2.6u
X436 ESD_RAIL a_1852_148519# VSS VSS nfet_06v0 ad=13.936p pd=54.12u as=13.936p ps=54.12u w=53.6u l=0.7u
X437 VSS a_1852_148519# ESD_RAIL VSS nfet_06v0 ad=13.936p pd=54.12u as=13.936p ps=54.12u w=53.6u l=0.7u
X438 ESD_RAIL a_1852_148519# VSS VSS nfet_06v0 ad=13.936p pd=54.12u as=23.584p ps=0.10808m w=53.6u l=0.7u
X439 VSS a_1852_148519# ESD_RAIL VSS nfet_06v0 ad=13.936p pd=54.12u as=13.936p ps=54.12u w=53.6u l=0.7u
X440 ESD_RAIL a_4789_117064# a_2245_90628# ESD_RAIL pfet_06v0 ad=2.2p pd=10.88u as=1.3p ps=5.52u w=5u l=0.7u
X441 VSS a_1852_148519# ESD_RAIL VSS nfet_06v0 ad=13.936p pd=54.12u as=13.936p ps=54.12u w=53.6u l=0.7u
X442 ESD_RAIL a_1852_148519# VSS VSS nfet_06v0 ad=13.936p pd=54.12u as=13.936p ps=54.12u w=53.6u l=0.7u
X443 VSS a_1852_148519# ESD_RAIL VSS nfet_06v0 ad=13.936p pd=54.12u as=13.936p ps=54.12u w=53.6u l=0.7u
X444 VSS a_2245_90628# ESD_RAIL VSS nfet_06v0 ad=13p pd=50.52u as=13p ps=50.52u w=50u l=0.7u
X445 RX_N VDD VDD VDD pfet_06v0 ad=1.76p pd=8.88u as=1.76p ps=8.88u w=4u l=0.55u
X446 a_1005_133505# a_13878_133785# ESD_RAIL ppolyf_u r_width=0.8u r_length=63.855u
X447 VSS a_2245_90628# ESD_RAIL VSS nfet_06v0 ad=13p pd=50.52u as=13p ps=50.52u w=50u l=0.7u
X448 a_73744_90254# TERM_ENABLE TERM_VCM VSS nfet_06v0 ad=8.8p pd=40.88u as=8.8p ps=40.88u w=20u l=0.7u
X449 a_75880_152046# TERM_ENABLE TERM_VCM VSS nfet_06v0 ad=8.8p pd=40.88u as=8.8p ps=40.88u w=20u l=0.7u
X450 ESD_RAIL a_1852_148519# VSS VSS nfet_06v0 ad=13.936p pd=54.12u as=13.936p ps=54.12u w=53.6u l=0.7u
X451 ESD_RAIL a_2245_90628# VSS VSS nfet_06v0 ad=13p pd=50.52u as=13p ps=50.52u w=50u l=0.7u
X452 ESD_RAIL a_1852_148519# VSS VSS nfet_06v0 ad=13.936p pd=54.12u as=13.936p ps=54.12u w=53.6u l=0.7u
X453 ESD_RAIL a_1852_148519# VSS VSS nfet_06v0 ad=13.936p pd=54.12u as=13.936p ps=54.12u w=53.6u l=0.7u
X454 ESD_RAIL a_1852_148519# VSS VSS nfet_06v0 ad=13.936p pd=54.12u as=13.936p ps=54.12u w=53.6u l=0.7u
X455 VSS a_1852_148519# ESD_RAIL VSS nfet_06v0 ad=13.936p pd=54.12u as=13.936p ps=54.12u w=53.6u l=0.7u
X456 a_73744_152046# TERM_ENABLE TERM_VCM VSS nfet_06v0 ad=8.8p pd=40.88u as=8.8p ps=40.88u w=20u l=0.7u
X457 ESD_RAIL a_2245_90628# VSS VSS nfet_06v0 ad=13p pd=50.52u as=13p ps=50.52u w=50u l=0.7u
X458 ESD_RAIL a_1852_148519# VSS VSS nfet_06v0 ad=13.936p pd=54.12u as=23.584p ps=0.10808m w=53.6u l=0.7u
X459 ESD_RAIL a_4789_117064# a_2245_90628# ESD_RAIL pfet_06v0 ad=1.3p pd=5.52u as=1.3p ps=5.52u w=5u l=0.7u
X460 a_94036_91054# TERM_TRIM3 TERM_VCM VSS nfet_06v0 ad=5.28p pd=24.88u as=5.28p ps=24.88u w=12u l=0.7u
X461 ESD_RAIL a_1852_148519# VSS VSS nfet_06v0 ad=13.936p pd=54.12u as=13.936p ps=54.12u w=53.6u l=0.7u
X462 a_2245_90628# VSS VSS ppolyf_u_1k_6p0 r_width=1u r_length=99.24u
X463 VSS a_1852_148519# ESD_RAIL VSS nfet_06v0 ad=13.936p pd=54.12u as=13.936p ps=54.12u w=53.6u l=0.7u
X464 VSS a_1852_148519# ESD_RAIL VSS nfet_06v0 ad=13.936p pd=54.12u as=13.936p ps=54.12u w=53.6u l=0.7u
X465 VSS a_1852_148519# ESD_RAIL VSS nfet_06v0 ad=13.936p pd=54.12u as=13.936p ps=54.12u w=53.6u l=0.7u
X466 VSS a_1852_148519# ESD_RAIL VSS nfet_06v0 ad=13.936p pd=54.12u as=13.936p ps=54.12u w=53.6u l=0.7u
D26 VSS PAD_N diode_nd2ps_06v0 pj=51.8u area=22.5p
X467 a_4789_117064# a_3813_117064# VSS VSS nfet_06v0 ad=1.3p pd=5.52u as=1.3p ps=5.52u w=5u l=0.7u
X468 PAD_P a_73744_90254# VSS ppolyf_u r_width=2u r_length=2.6u
X469 RX_N PAD_N cap_mim_2f0_m4m5_noshield c_width=35u c_length=35u
D27 VSS ESD_RAIL diode_nd2ps_06v0 pj=82u area=40p
X470 VSS a_1852_148519# ESD_RAIL VSS nfet_06v0 ad=13.936p pd=54.12u as=13.936p ps=54.12u w=53.6u l=0.7u
X471 VSS a_1852_148519# ESD_RAIL VSS nfet_06v0 ad=13.936p pd=54.12u as=13.936p ps=54.12u w=53.6u l=0.7u
X472 VSS a_2245_90628# ESD_RAIL VSS nfet_06v0 ad=13p pd=50.52u as=13p ps=50.52u w=50u l=0.7u
X473 VSS a_1852_148519# ESD_RAIL VSS nfet_06v0 ad=13.936p pd=54.12u as=13.936p ps=54.12u w=53.6u l=0.7u
X474 ESD_RAIL a_1852_148519# VSS VSS nfet_06v0 ad=13.936p pd=54.12u as=13.936p ps=54.12u w=53.6u l=0.7u
X475 VSS a_2245_90628# ESD_RAIL VSS nfet_06v0 ad=13p pd=50.52u as=13p ps=50.52u w=50u l=0.7u
X476 VSS a_2245_90628# ESD_RAIL VSS nfet_06v0 ad=13p pd=50.52u as=13p ps=50.52u w=50u l=0.7u
X477 ESD_RAIL a_1852_148519# VSS VSS nfet_06v0 ad=13.936p pd=54.12u as=13.936p ps=54.12u w=53.6u l=0.7u
X478 VSS a_2245_90628# ESD_RAIL VSS nfet_06v0 ad=13p pd=50.52u as=13p ps=50.52u w=50u l=0.7u
X479 PAD_P a_75880_90254# VSS ppolyf_u r_width=2u r_length=2.6u
C0 TERM_VCM a_91900_91054# 3.28801f
C1 TERM_VCM a_94036_152846# 2.32568f
C2 ESD_RAIL m3_31296_125300# 0.4985f
C3 TERM_VCM a_72676_152046# 2.42132f
C4 a_1005_131825# ESD_RAIL 0.53823f
C5 a_80152_152846# TERM_TRIM1 0.28932f
C6 a_1005_131545# a_1005_132945# 0
C7 PAD_N a_73744_152046# 0.04756f
C8 a_82288_152846# a_79084_152846# 0
C9 TERM_VCM a_70540_152046# 2.26906f
C10 TERM_VCM a_88696_91054# 2.2489f
C11 w_71178_112088# TERM_TRIM0 0.17102f
C12 TERM_TRIM3 w_71178_112088# 0.24351f
C13 a_1005_132385# ESD_RAIL 0.53823f
C14 TERM_VCM a_70540_90254# 2.26906f
C15 m4_29696_133300# m3_29696_133300# 0.15111f
C16 PAD_N m3_31296_117300# 0.03396f
C17 m4_32896_117300# m3_32896_117300# 0.15111f
C18 m4_31296_117300# m3_31296_117300# 0.15111f
C19 a_92968_91054# PAD_P 0.10003f
C20 TERM_ENABLE a_73744_90254# 0.42524f
C21 PAD_N VBIAS 0.15966f
C22 a_86560_152846# a_88696_152846# 0.2726f
C23 a_86560_152846# a_83356_152846# 0.01123f
C24 PAD_N a_79084_152846# 0.10321f
C25 a_92968_152846# TERM_TRIM3 0.28932f
C26 a_1005_132385# a_1005_132945# 0.0346f
C27 TERM_ENABLE a_71608_90254# 0.4243f
C28 TERM_ENABLE a_71608_152046# 0.4243f
C29 a_82288_91054# a_81220_91054# 0.10531f
C30 a_69448_149284# a_70540_152046# 0.13311f
C31 a_86560_152846# a_84424_152846# 0.17288f
C32 a_94036_91054# TERM_TRIM3 0.27606f
C33 a_81220_152846# a_78016_152046# 0
C34 a_75880_90254# TERM_ENABLE 0.4244f
C35 TERM_ENABLE a_78016_152046# 0.41103f
C36 TERM_VCM a_89764_152846# 2.00734f
C37 a_83356_91054# PAD_P 0.10313f
C38 a_82288_152846# a_83356_152846# 0.64368f
C39 a_91900_152846# a_88696_152846# 0.0331f
C40 a_84424_152846# a_82288_152846# 0.08318f
C41 a_90832_91054# a_89764_91054# 0.19968f
C42 PAD_N PAD_P 36.4223f
C43 TERM_VCM a_85492_152846# 2.14296f
C44 TERM_ENABLE a_68216_149284# 0.4243f
C45 a_80152_152846# a_78016_152046# 0.01596f
C46 PAD_N a_88696_152846# 0.10313f
C47 TERM_TRIM2 a_81220_91054# 0.01326f
C48 a_90832_152846# TERM_TRIM3 0.28932f
C49 PAD_N a_83356_152846# 0.10313f
C50 a_90832_152846# a_87628_152846# 0.31618f
C51 m3_34460_89900# PAD_P 0.04061f
C52 PAD_N a_84424_152846# 0.10313f
C53 a_92968_91054# a_91900_91054# 1.09827f
C54 TERM_VCM a_75880_152046# 2.29198f
C55 m4_34496_125300# PAD_P 0.01598f
C56 a_74812_90254# TERM_ENABLE 0.42606f
C57 PAD_N m4_29696_117300# 0.01425f
C58 m2_2279_124800# a_1005_134065# 0
C59 a_75880_90254# a_73744_90254# 0
C60 m4_29696_133300# PAD_N 0.01425f
C61 w_71178_112088# ESD_RAIL 0.08713f
C62 TERM_TRIM2 TERM_TRIM0 0.07657f
C63 TERM_TRIM2 TERM_TRIM3 49.1703f
C64 m3_34460_105900# PAD_N 0.04492f
C65 a_92968_91054# a_88696_91054# 0.00866f
C66 PAD_N m3_32896_117300# 0.03396f
C67 m3_29660_89900# PAD_P 0.03097f
C68 a_82288_91054# a_85492_91054# 0.00939f
C69 TERM_TRIM1 a_81220_91054# 0.27606f
C70 m3_32860_89900# ESD_RAIL 0
C71 PAD_P VBIAS 0.15544f
C72 m3_34496_133300# ESD_RAIL 0.4985f
C73 RX_P w_71178_112088# 2.17742f
C74 VDD w_71178_112088# 5.53293f
C75 a_78016_90254# PAD_P 0.04756f
C76 m3_29696_101300# ESD_RAIL 0.44823f
C77 a_91900_152846# a_94036_152846# 0.13174f
C78 TERM_VCM w_71178_112088# 0.37908f
C79 m4_31296_101300# ESD_RAIL 0.5351f
C80 TERM_ENABLE TERM_TRIM0 30.6415f
C81 TERM_ENABLE TERM_TRIM3 0.08127f
C82 ESD_RAIL m4_34496_133300# 0.5351f
C83 PAD_N a_94036_152846# 0.09836f
C84 a_72676_90254# TERM_ENABLE 0.4243f
C85 m3_29696_125300# m4_29696_125300# 0.15111f
C86 a_90832_91054# a_86560_91054# 0
C87 PAD_N a_72676_152046# 0.04756f
C88 a_74812_90254# a_73744_90254# 0.24052f
C89 TERM_VCM a_92968_152846# 2.42969f
C90 TERM_TRIM1 TERM_TRIM0 44.3258f
C91 TERM_TRIM3 TERM_TRIM1 0.08733f
C92 a_86560_152846# a_89764_152846# 0.02726f
C93 PAD_N a_70540_152046# 0.04756f
C94 m3_32896_101300# ESD_RAIL 0.4985f
C95 RX_N w_71178_112088# 2.17714f
C96 a_94036_91054# TERM_VCM 2.32568f
C97 a_86560_152846# a_85492_152846# 0.77991f
C98 TERM_TRIM2 a_85492_91054# 0.27606f
C99 a_87628_91054# PAD_P 0.10313f
C100 a_84424_91054# a_86560_91054# 0.17288f
C101 a_75880_90254# a_74812_90254# 0.15815f
C102 a_90832_91054# TERM_TRIM3 0.28932f
C103 TERM_VCM a_76948_152046# 2.67432f
C104 m4_29696_101300# m3_29696_101300# 0.15111f
C105 a_89764_91054# a_86560_91054# 0.02726f
C106 TERM_VCM a_82288_91054# 2.40617f
C107 m3_31296_133300# ESD_RAIL 0.4985f
C108 a_72676_152046# a_73744_152046# 0.14941f
C109 a_84424_152846# a_83356_152846# 0.26519f
C110 a_91900_152846# a_89764_152846# 0.16933f
C111 a_82288_152846# a_85492_152846# 0.00939f
C112 a_84424_91054# TERM_TRIM3 0
C113 a_72676_90254# a_73744_90254# 0.14941f
C114 m3_31260_89900# PAD_P 0.04061f
C115 TERM_VCM a_90832_152846# 2.01476f
C116 TERM_VCM a_74812_152046# 2.2233f
C117 a_13878_131545# a_13878_132105# 0.0346f
C118 a_82288_91054# a_79084_91054# 0
C119 PAD_N a_89764_152846# 0.10313f
C120 a_13878_134345# ESD_RAIL 0.5677f
C121 m4_31296_101300# m3_31296_101300# 0.15111f
C122 a_89764_91054# TERM_TRIM3 0.28932f
C123 a_72676_90254# a_71608_90254# 0.14045f
C124 a_68216_96914# PAD_P 0.12057f
C125 m3_32860_105900# PAD_N 0.04492f
C126 ESD_RAIL m3_32896_133300# 0.4985f
C127 a_3813_117064# a_2245_90628# 0.00994f
C128 a_82288_91054# a_80152_91054# 0.03597f
C129 PAD_N a_85492_152846# 0.10313f
C130 m4_31296_125300# ESD_RAIL 0.5351f
C131 RX_P TERM_TRIM2 0.14387f
C132 VDD TERM_TRIM2 0.28557f
C133 TERM_TRIM0 a_78016_152046# 0.00894f
C134 a_3813_117064# a_1005_131545# 2.44008f
C135 a_13878_132105# a_13878_132665# 0.0346f
C136 TERM_VCM TERM_TRIM2 5.12464f
C137 a_69448_96914# PAD_P 0.04756f
C138 a_87628_91054# a_91900_91054# 0.00449f
C139 a_13878_133785# a_13878_134345# 0.0346f
C140 PAD_N a_75880_152046# 0.04756f
C141 PAD_P a_91900_91054# 0.10003f
C142 m3_29696_117300# ESD_RAIL 0.44823f
C143 m4_32896_133300# ESD_RAIL 0.5351f
C144 m3_32896_125300# m4_32896_125300# 0.15111f
C145 RX_P TERM_ENABLE 0
C146 VDD TERM_ENABLE 12.9618f
C147 a_87628_91054# a_88696_91054# 0.85754f
C148 TERM_VCM a_81220_152846# 1.99423f
C149 m4_31296_133300# m3_31296_133300# 0.15111f
C150 a_1005_134065# ESD_RAIL 0.57348f
C151 a_84424_91054# a_85492_91054# 0.72556f
C152 a_94036_91054# a_92968_91054# 1.15263f
C153 PAD_P a_88696_91054# 0.10313f
C154 TERM_VCM TERM_ENABLE 25.0657f
C155 a_70540_90254# PAD_P 0.04756f
C156 RX_P TERM_TRIM1 0.14387f
C157 VDD TERM_TRIM1 0.28454f
C158 a_89764_91054# a_85492_91054# 0.00355f
C159 ESD_RAIL m4_32896_101300# 0.5351f
C160 a_74812_90254# a_72676_90254# 0
C161 TERM_VCM TERM_TRIM1 3.78482f
C162 m3_31296_125300# PAD_P 0.03396f
C163 m3_32896_125300# ESD_RAIL 0.4985f
C164 a_75880_152046# a_73744_152046# 0
C165 a_68216_96914# a_69448_96914# 0.13125f
C166 TERM_ENABLE a_79084_91054# 0.00349f
C167 PAD_N w_71178_112088# 7.24362f
C168 TERM_ENABLE a_76948_90254# 0.42442f
C169 TERM_ENABLE a_69448_149284# 0.4243f
C170 TERM_TRIM3 a_86560_91054# 0.28932f
C171 RX_N TERM_ENABLE 0.14434f
C172 a_80152_152846# TERM_VCM 2.24523f
C173 a_91900_152846# a_92968_152846# 1.09827f
C174 TERM_TRIM1 a_79084_91054# 0.01327f
C175 TERM_VCM a_90832_91054# 2.01476f
C176 a_86560_152846# a_90832_152846# 0
C177 a_92968_152846# PAD_N 0.10003f
C178 m4_34496_101300# m3_34496_101300# 0.15111f
C179 m4_34496_101300# ESD_RAIL 0.5351f
C180 m3_34496_133300# PAD_N 0.03396f
C181 TERM_TRIM1 a_80152_91054# 0.28932f
C182 m4_29696_125300# ESD_RAIL 0.48045f
C183 a_88696_152846# a_89764_152846# 0.94068f
C184 TERM_TRIM3 TERM_TRIM0 0.07988f
C185 a_87628_152846# TERM_TRIM3 0.28935f
C186 TERM_VCM a_73744_90254# 2.49447f
C187 a_82288_91054# a_83356_91054# 0.64368f
C188 PAD_N m4_34496_133300# 0.02435f
C189 TERM_VCM a_84424_91054# 3.02567f
C190 PAD_N a_76948_152046# 0.04756f
C191 a_88696_152846# a_85492_152846# 0.01848f
C192 a_85492_152846# a_83356_152846# 0.1405f
C193 a_69448_96914# a_70540_90254# 0.13311f
C194 TERM_VCM a_71608_90254# 2.35823f
C195 m3_29696_125300# ESD_RAIL 0.44823f
C196 TERM_VCM a_71608_152046# 2.35823f
C197 a_91900_91054# a_88696_91054# 0.0331f
C198 a_4789_117064# ESD_RAIL 16.8853f
C199 TERM_VCM a_89764_91054# 2.00734f
C200 m2_2279_124800# ESD_RAIL 5.47988f
C201 a_84424_152846# a_85492_152846# 0.72556f
C202 w_71178_112088# VBIAS 1.98187f
C203 TERM_VCM a_75880_90254# 2.29198f
C204 a_91900_152846# a_90832_152846# 0.09974f
C205 a_1005_133505# a_1005_134065# 0.0346f
C206 a_13878_131545# ESD_RAIL 0.56772f
C207 TERM_VCM a_78016_152046# 2.25881f
C208 a_85492_91054# a_86560_91054# 0.77991f
C209 a_90832_152846# PAD_N 0.1091f
C210 m2_2279_124800# a_1005_132945# 0
C211 PAD_N a_74812_152046# 0.04756f
C212 a_13878_132105# ESD_RAIL 0.53942f
C213 TERM_TRIM2 a_82288_152846# 0.28932f
C214 a_2245_90628# a_1005_131545# 0.01301f
C215 ESD_RAIL m3_34496_125300# 0.4985f
C216 a_83356_91054# TERM_TRIM2 0.28932f
C217 PAD_N m3_31296_133300# 0.03396f
C218 a_75880_90254# a_76948_90254# 0.24993f
C219 a_13878_132665# ESD_RAIL 0.53916f
C220 TERM_VCM a_68216_149284# 2.07251f
C221 PAD_N TERM_TRIM2 0.25684f
C222 TERM_TRIM3 a_85492_91054# 0.01326f
C223 a_89764_152846# a_94036_152846# 0.0102f
C224 w_71178_112088# PAD_P 0.75903f
C225 a_79084_152846# a_76948_152046# 0.01248f
C226 a_1005_131545# a_1005_131825# 0.03725f
C227 a_82288_152846# a_81220_152846# 0.10531f
C228 a_73744_152046# a_74812_152046# 0.24052f
C229 TERM_VCM a_74812_90254# 2.2233f
C230 PAD_N m3_32896_133300# 0.03396f
C231 a_90832_91054# a_92968_91054# 0
C232 a_1005_131545# a_1005_132385# 0
C233 a_69448_149284# a_68216_149284# 0.13125f
C234 m3_32860_89900# PAD_P 0.04061f
C235 PAD_N a_81220_152846# 0.10746f
C236 a_92968_152846# a_88696_152846# 0.00866f
C237 a_1005_131825# a_1005_132385# 0.0346f
C238 PAD_N TERM_ENABLE 0.33094f
C239 TERM_VCM a_86560_91054# 2.01082f
C240 TERM_VCM a_81220_91054# 1.99423f
C241 m3_29696_101300# PAD_P 0.02453f
C242 a_94036_91054# PAD_P 0.09836f
C243 m4_31296_101300# PAD_P 0.01598f
C244 a_80152_152846# a_82288_152846# 0.03597f
C245 m2_2279_124800# a_1005_133505# 0
C246 PAD_N m3_29696_117300# 0.02453f
C247 PAD_N TERM_TRIM1 0.25684f
C248 a_92968_91054# a_89764_91054# 0.12994f
C249 RX_P TERM_TRIM0 0.16216f
C250 RX_P TERM_TRIM3 0.14387f
C251 TERM_TRIM2 VBIAS 0.17974f
C252 VDD TERM_TRIM0 0.28403f
C253 a_82288_91054# PAD_P 0.10313f
C254 a_81220_91054# a_79084_91054# 0.13387f
C255 VDD TERM_TRIM3 4.05215f
C256 PAD_N m4_32896_133300# 0.01598f
C257 a_80152_152846# PAD_N 0.10321f
C258 TERM_VCM TERM_TRIM0 4.39961f
C259 TERM_VCM TERM_TRIM3 7.81019f
C260 TERM_VCM a_87628_152846# 3.22474f
C261 m3_32896_101300# PAD_P 0.03396f
C262 TERM_VCM a_72676_90254# 2.42132f
C263 a_81220_91054# a_80152_91054# 0.25062f
C264 TERM_ENABLE a_73744_152046# 0.42524f
C265 a_89764_152846# a_85492_152846# 0.00355f
C266 a_90832_152846# a_88696_152846# 0.13655f
C267 a_84424_91054# a_83356_91054# 0.26519f
C268 a_79084_91054# TERM_TRIM0 0.27606f
C269 TERM_ENABLE VBIAS 0.34917f
C270 ESD_RAIL m4_34496_117300# 0.5351f
C271 a_81220_152846# a_79084_152846# 0.13387f
C272 TERM_ENABLE a_78016_90254# 0.41103f
C273 TERM_ENABLE a_79084_152846# 0.00349f
C274 a_92968_152846# a_94036_152846# 1.15263f
C275 m4_32896_125300# ESD_RAIL 0.5351f
C276 TERM_TRIM2 PAD_P 0.07529f
C277 TERM_TRIM1 VBIAS 0.17732f
C278 PAD_N a_71608_152046# 0.04756f
C279 a_94036_91054# a_91900_91054# 0.13174f
C280 TERM_TRIM1 a_79084_152846# 0.01327f
C281 TERM_TRIM2 a_83356_152846# 0.28932f
C282 PAD_N a_78016_152046# 0.04756f
C283 ESD_RAIL m3_34496_101300# 0.4985f
C284 TERM_TRIM2 a_84424_152846# 0.28933f
C285 a_80152_152846# a_79084_152846# 0.46856f
C286 TERM_VCM a_85492_91054# 2.14296f
C287 m4_31296_125300# PAD_P 0.01598f
C288 TERM_ENABLE PAD_P 0.09923f
C289 a_1005_132945# ESD_RAIL 0.53823f
C290 a_81220_152846# a_83356_152846# 0
C291 PAD_N a_68216_149284# 0.12057f
C292 a_90832_152846# a_94036_152846# 0.00419f
C293 TERM_TRIM1 PAD_P 0.07651f
C294 a_13878_133785# ESD_RAIL 0.53942f
C295 a_72676_152046# a_74812_152046# 0
C296 a_86560_152846# TERM_TRIM3 0.28932f
C297 a_92968_91054# TERM_TRIM3 0.28932f
C298 a_86560_152846# a_87628_152846# 0.18097f
C299 a_92968_152846# a_89764_152846# 0.12994f
C300 a_90832_91054# a_87628_91054# 0.31618f
C301 m4_29696_101300# ESD_RAIL 0.48045f
C302 ESD_RAIL a_1852_148519# 0.3438p
C303 a_83356_91054# a_81220_91054# 0
C304 a_83356_91054# a_86560_91054# 0.01123f
C305 VDD RX_P 2.31443f
C306 m3_29696_117300# m4_29696_117300# 0.15111f
C307 a_90832_91054# PAD_P 0.1091f
C308 a_80152_152846# a_83356_152846# 0.00715f
C309 a_75880_90254# a_78016_90254# 0.01025f
C310 a_68216_96914# TERM_ENABLE 0.4243f
C311 PAD_P m4_32896_101300# 0.01598f
C312 a_79084_152846# a_78016_152046# 0.27297f
C313 TERM_VCM RX_P 6.30872f
C314 TERM_VCM VDD 3.62756f
C315 m3_32896_125300# PAD_P 0.03396f
C316 m4_34496_125300# m3_34496_125300# 0.15111f
C317 a_73744_90254# PAD_P 0.04756f
C318 a_3813_117064# a_4789_117064# 3.03168f
C319 m3_31296_101300# ESD_RAIL 0.4985f
C320 a_84424_91054# a_87628_91054# 0.01397f
C321 a_84424_91054# PAD_P 0.10313f
C322 m4_31296_133300# ESD_RAIL 0.5351f
C323 TERM_ENABLE a_69448_96914# 0.4243f
C324 a_71608_90254# PAD_P 0.04756f
C325 a_89764_91054# a_87628_91054# 0.12483f
C326 m4_32896_117300# ESD_RAIL 0.5351f
C327 a_91900_152846# TERM_TRIM3 0.2894f
C328 a_1005_133505# ESD_RAIL 0.53842f
C329 RX_P RX_N 3.37337f
C330 a_91900_152846# a_87628_152846# 0.00449f
C331 VDD RX_N 8.13768f
C332 a_89764_91054# PAD_P 0.10313f
C333 TERM_VCM a_79084_91054# 2.71834f
C334 TERM_VCM a_76948_90254# 2.67432f
C335 TERM_VCM a_69448_149284# 2.21943f
C336 m4_34496_101300# PAD_P 0.01598f
C337 PAD_N TERM_TRIM0 0.25684f
C338 PAD_N TERM_TRIM3 0.40303f
C339 a_90832_152846# a_89764_152846# 0.19968f
C340 TERM_VCM RX_N 6.84313f
C341 a_87628_152846# PAD_N 0.10313f
C342 TERM_ENABLE a_72676_152046# 0.4243f
C343 m3_29696_133300# ESD_RAIL 0.44823f
C344 m4_29696_125300# PAD_P 0.01425f
C345 a_75880_90254# PAD_P 0.04756f
C346 TERM_VCM a_80152_91054# 2.24523f
C347 a_75880_152046# a_76948_152046# 0.24993f
C348 a_1005_132945# a_1005_133505# 0.0346f
C349 TERM_ENABLE a_70540_152046# 0.4243f
C350 m3_29660_105900# ESD_RAIL -0
C351 m3_34496_117300# m4_34496_117300# 0.15111f
C352 TERM_ENABLE a_70540_90254# 0.4243f
C353 a_79084_91054# a_76948_90254# 0.01248f
C354 m4_31296_125300# m3_31296_125300# 0.15111f
C355 m3_29696_125300# PAD_P 0.02453f
C356 a_80152_91054# a_79084_91054# 0.46856f
C357 a_90832_91054# a_91900_91054# 0.09974f
C358 a_78016_90254# a_81220_91054# 0
C359 a_75880_152046# a_74812_152046# 0.15815f
C360 TERM_TRIM2 a_85492_152846# 0.27606f
C361 a_13878_133225# a_13878_132665# 0.0346f
C362 m3_34496_117300# ESD_RAIL 0.4985f
C363 a_83356_91054# a_85492_91054# 0.1405f
C364 a_90832_91054# a_88696_91054# 0.13655f
C365 a_74812_90254# PAD_P 0.04756f
C366 VBIAS TERM_TRIM0 0.17628f
C367 TERM_TRIM3 VBIAS 4.00884f
C368 PAD_P m3_34496_125300# 0.03396f
C369 PAD_N m4_34496_117300# 0.02435f
C370 a_79084_152846# TERM_TRIM0 0.27606f
C371 a_78016_90254# TERM_TRIM0 0.00894f
C372 a_89764_91054# a_91900_91054# 0.16933f
C373 a_87628_91054# a_86560_91054# 0.18097f
C374 a_72676_152046# a_71608_152046# 0.14045f
C375 TERM_VCM a_86560_152846# 2.01082f
C376 m3_34496_133300# m4_34496_133300# 0.15111f
C377 TERM_VCM a_92968_91054# 2.42969f
C378 a_81220_91054# PAD_P 0.10746f
C379 PAD_P a_86560_91054# 0.10313f
C380 a_70540_152046# a_71608_152046# 0.13588f
C381 a_71608_90254# a_70540_90254# 0.13588f
C382 a_89764_91054# a_88696_91054# 0.94068f
C383 PAD_N ESD_RAIL 50.7909f
C384 m4_31296_117300# ESD_RAIL 0.5351f
C385 TERM_ENABLE a_75880_152046# 0.4244f
C386 a_92968_152846# a_90832_152846# 0
C387 TERM_TRIM3 a_87628_91054# 0.28935f
C388 PAD_P TERM_TRIM0 0.08989f
C389 TERM_TRIM3 PAD_P 0.13496f
C390 ESD_RAIL m3_34460_89900# 0
C391 TERM_VCM a_82288_152846# 2.40617f
C392 a_72676_90254# PAD_P 0.04756f
C393 TERM_TRIM2 w_71178_112088# 0.14534f
C394 TERM_TRIM3 a_88696_152846# 0.28932f
C395 a_87628_152846# a_88696_152846# 0.85754f
C396 TERM_VCM a_83356_91054# 2.01072f
C397 m4_34496_125300# ESD_RAIL 0.5351f
C398 VDD PAD_N 0.39442f
C399 TERM_VCM a_91900_152846# 3.28801f
C400 a_4789_117064# a_2245_90628# 11.6307f
C401 TERM_TRIM3 a_84424_152846# 0
C402 a_87628_152846# a_84424_152846# 0.01397f
C403 TERM_VCM PAD_N 4.46952f
C404 a_4789_117064# a_1005_131545# 0.02926f
C405 m2_2279_124800# a_1005_131545# 0.05457f
C406 m3_31296_117300# ESD_RAIL 0.4985f
C407 TERM_ENABLE w_71178_112088# 16.5641f
C408 PAD_N a_1852_148519# 0.106f
C409 m3_29660_89900# ESD_RAIL 0
C410 a_83356_91054# a_80152_91054# 0.00715f
C411 m2_2279_124800# a_1005_131825# 0
C412 a_3813_117064# ESD_RAIL 5.25092f
C413 PAD_N a_69448_149284# 0.04756f
C414 PAD_N RX_N 16.0706f
C415 TERM_TRIM1 w_71178_112088# 0.1509f
C416 a_82288_91054# TERM_TRIM2 0.28932f
C417 m2_2279_124800# a_1005_132385# 0
C418 a_85492_91054# a_87628_91054# 0.21991f
C419 TERM_VCM a_73744_152046# 2.49447f
C420 a_85492_91054# PAD_P 0.10313f
C421 a_88696_91054# a_86560_91054# 0.2726f
C422 m4_31296_133300# PAD_N 0.01598f
C423 m4_32896_125300# PAD_P 0.01598f
C424 RX_P VBIAS 0.079f
C425 TERM_TRIM3 a_91900_91054# 0.2894f
C426 VDD VBIAS 6.80037f
C427 PAD_N m4_32896_117300# 0.01598f
C428 a_13878_133225# ESD_RAIL 0.53916f
C429 TERM_TRIM3 a_94036_152846# 0.27606f
C430 a_75880_152046# a_78016_152046# 0.01025f
C431 TERM_VCM VBIAS 15.9004f
C432 TERM_ENABLE a_76948_152046# 0.42442f
C433 TERM_VCM a_78016_90254# 2.25881f
C434 TERM_VCM a_79084_152846# 2.71834f
C435 PAD_N m3_29696_133300# 0.02453f
C436 PAD_P m3_34496_101300# 0.03396f
C437 ESD_RAIL PAD_P 56.6713f
C438 TERM_TRIM3 a_88696_91054# 0.28932f
C439 PAD_N m3_29660_105900# 0.03097f
C440 a_94036_91054# a_90832_91054# 0.00419f
C441 RX_N VBIAS 0.24116f
C442 a_78016_90254# a_79084_91054# 0.27297f
C443 a_13878_133785# a_13878_133225# 0.0346f
C444 TERM_ENABLE a_74812_152046# 0.42606f
C445 a_78016_90254# a_76948_90254# 0.43572f
C446 ESD_RAIL m4_29696_117300# 0.48045f
C447 a_78016_90254# a_80152_91054# 0.01596f
C448 RX_P PAD_P 16.0706f
C449 VDD PAD_P 0.39442f
C450 a_86560_152846# PAD_N 0.10313f
C451 TERM_VCM a_87628_91054# 3.22474f
C452 m3_31260_89900# ESD_RAIL 0
C453 TERM_VCM PAD_P 4.08609f
C454 m4_29696_133300# ESD_RAIL 0.48045f
C455 TERM_TRIM2 a_81220_152846# 0.01326f
C456 m3_34496_117300# PAD_N 0.03396f
C457 TERM_VCM a_88696_152846# 2.2489f
C458 TERM_TRIM2 TERM_ENABLE 0.07746f
C459 TERM_VCM a_83356_152846# 2.01072f
C460 TERM_TRIM3 a_89764_152846# 0.28932f
C461 a_94036_91054# a_89764_91054# 0.0102f
C462 ESD_RAIL m3_32896_117300# 0.4985f
C463 a_87628_152846# a_89764_152846# 0.12483f
C464 m3_32896_101300# m4_32896_101300# 0.15111f
C465 m4_29696_101300# PAD_P 0.01425f
C466 PAD_P a_1852_148519# 0.25621f
C467 TERM_VCM a_84424_152846# 3.02567f
C468 TERM_TRIM2 TERM_TRIM1 46.0549f
C469 a_79084_91054# PAD_P 0.10321f
C470 a_82288_91054# a_84424_91054# 0.08318f
C471 PAD_P a_76948_90254# 0.04756f
C472 TERM_TRIM3 a_85492_152846# 0.01326f
C473 a_87628_152846# a_85492_152846# 0.21991f
C474 PAD_N a_82288_152846# 0.10313f
C475 a_85492_91054# a_88696_91054# 0.01848f
C476 a_80152_91054# PAD_P 0.10321f
C477 m3_31296_101300# PAD_P 0.03396f
C478 a_78016_152046# a_76948_152046# 0.43572f
C479 a_91900_152846# PAD_N 0.10003f
C480 TERM_VCM a_68216_96914# 2.07251f
C481 m4_32896_133300# m3_32896_133300# 0.15111f
C482 m4_31296_117300# PAD_N 0.01598f
C483 a_81220_152846# TERM_TRIM1 0.27606f
C484 TERM_ENABLE TERM_TRIM1 0.09198f
C485 a_2245_90628# ESD_RAIL 0.24349p
C486 PAD_N m3_31260_105900# 0.04492f
C487 a_80152_152846# a_81220_152846# 0.25062f
C488 a_84424_91054# TERM_TRIM2 0.28933f
C489 TERM_VCM a_69448_96914# 2.21943f
C490 a_1005_131545# ESD_RAIL 97.1325f
C491 RX_P VSS 43.3929f
C492 VBIAS VSS 8.6617f
C493 RX_N VSS 37.5203f
C494 PAD_P VSS 0.42273p
C495 PAD_N VSS 0.40526p
C496 TERM_TRIM3 VSS 62.7203f
C497 TERM_TRIM2 VSS 20.8792f
C498 TERM_TRIM1 VSS 13.0932f
C499 TERM_TRIM0 VSS 13.0174f
C500 TERM_VCM VSS 0.2863p
C501 TERM_ENABLE VSS 40.1365f
C502 VDD VSS 31.8661f
C503 ESD_RAIL VSS 3263.27133f
C504 m4_34496_101300# VSS 0.06434f $ **FLOATING
C505 m4_32896_101300# VSS 0.06434f $ **FLOATING
C506 m4_31296_101300# VSS 0.06434f $ **FLOATING
C507 m4_29696_101300# VSS 0.12191f $ **FLOATING
C508 m4_34496_117300# VSS 0.05645f $ **FLOATING
C509 m4_32896_117300# VSS 0.06434f $ **FLOATING
C510 m4_31296_117300# VSS 0.06434f $ **FLOATING
C511 m4_29696_117300# VSS 0.12191f $ **FLOATING
C512 m4_34496_125300# VSS 0.06434f $ **FLOATING
C513 m4_32896_125300# VSS 0.06434f $ **FLOATING
C514 m4_31296_125300# VSS 0.06434f $ **FLOATING
C515 m4_29696_125300# VSS 0.12191f $ **FLOATING
C516 m4_34496_133300# VSS 0.05645f $ **FLOATING
C517 m4_32896_133300# VSS 0.06434f $ **FLOATING
C518 m4_31296_133300# VSS 0.06434f $ **FLOATING
C519 m4_29696_133300# VSS 0.12191f $ **FLOATING
C520 m3_34460_89900# VSS 1.1519f $ **FLOATING
C521 m3_32860_89900# VSS 1.1519f $ **FLOATING
C522 m3_31260_89900# VSS 1.1519f $ **FLOATING
C523 m3_29660_89900# VSS 1.16765f $ **FLOATING
C524 m3_34496_101300# VSS 0.07041f $ **FLOATING
C525 m3_32896_101300# VSS 0.07041f $ **FLOATING
C526 m3_31296_101300# VSS 0.07041f $ **FLOATING
C527 m3_29696_101300# VSS 0.13352f $ **FLOATING
C528 m3_34460_105900# VSS 1.14905f $ **FLOATING
C529 m3_32860_105900# VSS 1.14905f $ **FLOATING
C530 m3_31260_105900# VSS 1.14905f $ **FLOATING
C531 m3_29660_105900# VSS 1.16802f $ **FLOATING
C532 m3_34496_117300# VSS 0.07041f $ **FLOATING
C533 m3_32896_117300# VSS 0.07041f $ **FLOATING
C534 m3_31296_117300# VSS 0.07041f $ **FLOATING
C535 m3_29696_117300# VSS 0.13352f $ **FLOATING
C536 m3_34496_125300# VSS 0.07041f $ **FLOATING
C537 m3_32896_125300# VSS 0.07041f $ **FLOATING
C538 m3_31296_125300# VSS 0.07041f $ **FLOATING
C539 m3_29696_125300# VSS 0.13352f $ **FLOATING
C540 m3_34496_133300# VSS 0.07041f $ **FLOATING
C541 m3_32896_133300# VSS 0.07041f $ **FLOATING
C542 m3_31296_133300# VSS 0.07041f $ **FLOATING
C543 m3_29696_133300# VSS 0.13352f $ **FLOATING
C544 m2_2279_124800# VSS 7.46506f $ **FLOATING
C545 a_94036_91054# VSS 5.2243f
C546 a_92968_91054# VSS 3.93112f
C547 a_91900_91054# VSS 3.90351f
C548 a_90832_91054# VSS 5.23471f
C549 a_89764_91054# VSS 4.68749f
C550 a_88696_91054# VSS 3.6362f
C551 a_87628_91054# VSS 3.41078f
C552 a_86560_91054# VSS 4.50343f
C553 a_85492_91054# VSS 3.69571f
C554 a_84424_91054# VSS 3.5367f
C555 a_83356_91054# VSS 4.36699f
C556 a_82288_91054# VSS 3.77529f
C557 a_81220_91054# VSS 4.50674f
C558 a_80152_91054# VSS 3.8859f
C559 a_79084_91054# VSS 3.5515f
C560 a_78016_90254# VSS 4.46223f
C561 a_76948_90254# VSS 4.23258f
C562 a_75880_90254# VSS 4.38204f
C563 a_74812_90254# VSS 4.52145f
C564 a_73744_90254# VSS 4.22946f
C565 a_72676_90254# VSS 4.2378f
C566 a_71608_90254# VSS 4.2058f
C567 a_70540_90254# VSS 4.09517f
C568 a_69448_96914# VSS 4.10477f
C569 a_68216_96914# VSS 4.20114f
C570 a_2245_90628# VSS 0.24972p
C571 a_4789_117064# VSS 8.91806f
C572 a_3813_117064# VSS 5.17875f
C573 a_1005_131545# VSS 98.15211f
C574 a_13878_131545# VSS 0.07835f
C575 a_1005_131825# VSS 0.07377f
C576 a_13878_132105# VSS 0.07394f
C577 a_1005_132385# VSS 0.07377f
C578 a_13878_132665# VSS 0.07394f
C579 a_1005_132945# VSS 0.07377f
C580 a_13878_133225# VSS 0.07394f
C581 a_1005_133505# VSS 0.07377f
C582 a_13878_133785# VSS 0.07394f
C583 a_1005_134065# VSS 0.07377f
C584 a_13878_134345# VSS 0.07838f
C585 a_94036_152846# VSS 5.2243f
C586 a_92968_152846# VSS 3.93112f
C587 a_91900_152846# VSS 3.90351f
C588 a_90832_152846# VSS 5.23471f
C589 a_89764_152846# VSS 4.68749f
C590 a_88696_152846# VSS 3.6362f
C591 a_87628_152846# VSS 3.41078f
C592 a_86560_152846# VSS 4.50343f
C593 a_85492_152846# VSS 3.69571f
C594 a_84424_152846# VSS 3.5367f
C595 a_83356_152846# VSS 4.36699f
C596 a_82288_152846# VSS 3.77529f
C597 a_81220_152846# VSS 4.50674f
C598 a_80152_152846# VSS 3.8859f
C599 a_79084_152846# VSS 3.5515f
C600 a_78016_152046# VSS 4.46223f
C601 a_76948_152046# VSS 4.23258f
C602 a_75880_152046# VSS 4.38204f
C603 a_74812_152046# VSS 4.52145f
C604 a_73744_152046# VSS 4.22946f
C605 a_72676_152046# VSS 4.2378f
C606 a_71608_152046# VSS 4.2058f
C607 a_70540_152046# VSS 4.09517f
C608 a_69448_149284# VSS 4.10477f
C609 a_68216_149284# VSS 4.20114f
C610 a_1852_148519# VSS 0.41778p
C611 w_71178_112088# VSS 50.1311f
DWELL_ARRAY VSS ESD_RAIL diode_nw2ps_06v0 area=1138.9056p pj=941.44u
.ends
