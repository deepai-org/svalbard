.subckt hs_protected_pad VSS VDD TERM_VCM TERM_ENABLE TERM_TRIM0 TERM_TRIM1 TERM_TRIM2 TERM_TRIM3 VBIAS RX_P RX_N PAD_P PAD_N
XPHYSICAL ESD_RAIL VSS VDD TERM_VCM TERM_ENABLE TERM_TRIM0 TERM_TRIM1 TERM_TRIM2 TERM_TRIM3 VBIAS RX_P RX_N PAD_P PAD_N pad_hspad_flat
.ends hs_protected_pad
* NGSPICE file created from pad_hspad_flat.ext - technology: gf180mcuD

.subckt pad_hspad_flat ESD_RAIL VSS VDD TERM_VCM TERM_ENABLE TERM_TRIM0 TERM_TRIM1
+ TERM_TRIM2 TERM_TRIM3 VBIAS RX_P RX_N PAD_P PAD_N
X0 PAD_P a_37904_193969# VSS ppolyf_u r_width=2u r_length=2u
X1 ESD_RAIL a_1852_148519# VSS VSS nfet_06v0 ad=13.936p pd=54.12u as=13.936p ps=54.12u w=53.6u l=0.7u
X2 ESD_RAIL a_1852_148519# VSS VSS nfet_06v0 ad=13.936p pd=54.12u as=13.936p ps=54.12u w=53.6u l=0.7u
X3 ESD_RAIL a_2245_90628# VSS VSS nfet_06v0 ad=22p pd=0.10088m as=13p ps=50.52u w=50u l=0.7u
X4 a_1005_133505# a_13878_133225# ESD_RAIL ppolyf_u r_width=0.8u r_length=63.855u
X5 ESD_RAIL a_1852_148519# VSS VSS nfet_06v0 ad=13.936p pd=54.12u as=23.584p ps=0.10808m w=53.6u l=0.7u
X6 ESD_RAIL a_1852_148519# VSS VSS nfet_06v0 ad=13.936p pd=54.12u as=13.936p ps=54.12u w=53.6u l=0.7u
X7 VSS a_1852_148519# ESD_RAIL VSS nfet_06v0 ad=13.936p pd=54.12u as=13.936p ps=54.12u w=53.6u l=0.7u
X8 VSS a_2245_90628# ESD_RAIL VSS nfet_06v0 ad=13p pd=50.52u as=13p ps=50.52u w=50u l=0.7u
X9 VSS a_1852_148519# ESD_RAIL VSS nfet_06v0 ad=13.936p pd=54.12u as=13.936p ps=54.12u w=53.6u l=0.7u
X10 ESD_RAIL a_1852_148519# VSS VSS nfet_06v0 ad=13.936p pd=54.12u as=13.936p ps=54.12u w=53.6u l=0.7u
X11 PAD_N a_88032_188004# VSS ppolyf_u r_width=2u r_length=2u
D0 PAD_P ESD_RAIL diode_pd2nw_06v0 pj=51.8u area=22.5p
X12 TERM_VCM TERM_TRIM3 a_34208_193969# VSS nfet_06v0 ad=5.28p pd=24.88u as=5.28p ps=24.88u w=12u l=0.7u
X13 VSS a_1852_148519# ESD_RAIL VSS nfet_06v0 ad=13.936p pd=54.12u as=13.936p ps=54.12u w=53.6u l=0.7u
X14 ESD_RAIL a_2245_90628# VSS VSS nfet_06v0 ad=22p pd=0.10088m as=13p ps=50.52u w=50u l=0.7u
X15 ESD_RAIL a_4789_117064# a_2245_90628# ESD_RAIL pfet_06v0 ad=1.3p pd=5.52u as=1.3p ps=5.52u w=5u l=0.7u
X16 TERM_VCM TERM_TRIM3 a_31744_193969# VSS nfet_06v0 ad=5.28p pd=24.88u as=5.28p ps=24.88u w=12u l=0.7u
X17 ESD_RAIL a_1852_148519# VSS VSS nfet_06v0 ad=13.936p pd=54.12u as=13.936p ps=54.12u w=53.6u l=0.7u
X18 ESD_RAIL a_4789_117064# a_2245_90628# ESD_RAIL pfet_06v0 ad=1.3p pd=5.52u as=1.3p ps=5.52u w=5u l=0.7u
X19 ESD_RAIL a_1852_148519# VSS VSS nfet_06v0 ad=13.936p pd=54.12u as=13.936p ps=54.12u w=53.6u l=0.7u
X20 ESD_RAIL a_2245_90628# VSS VSS nfet_06v0 ad=13p pd=50.52u as=13p ps=50.52u w=50u l=0.7u
X21 VSS a_1852_148519# ESD_RAIL VSS nfet_06v0 ad=13.936p pd=54.12u as=13.936p ps=54.12u w=53.6u l=0.7u
X22 a_69876_187204# TERM_ENABLE TERM_VCM VSS nfet_06v0 ad=8.8p pd=40.88u as=8.8p ps=40.88u w=20u l=0.7u
X23 PAD_N a_90168_188004# VSS ppolyf_u r_width=2u r_length=2u
X24 ESD_RAIL a_13878_134345# ESD_RAIL ppolyf_u r_width=0.8u r_length=63.855u
X25 VSS a_1852_148519# ESD_RAIL VSS nfet_06v0 ad=13.936p pd=54.12u as=13.936p ps=54.12u w=53.6u l=0.7u
X26 ESD_RAIL a_1852_148519# VSS VSS nfet_06v0 ad=13.936p pd=54.12u as=13.936p ps=54.12u w=53.6u l=0.7u
X27 ESD_RAIL a_1852_148519# VSS VSS nfet_06v0 ad=13.936p pd=54.12u as=13.936p ps=54.12u w=53.6u l=0.7u
X28 ESD_RAIL a_1852_148519# VSS VSS nfet_06v0 ad=13.936p pd=54.12u as=13.936p ps=54.12u w=53.6u l=0.7u
D1 VSS PAD_P diode_nd2ps_06v0 pj=51.8u area=22.5p
X29 VSS a_1852_148519# ESD_RAIL VSS nfet_06v0 ad=13.936p pd=54.12u as=13.936p ps=54.12u w=53.6u l=0.7u
X30 PAD_N a_81624_188004# VSS ppolyf_u r_width=2u r_length=2u
X31 PAD_P a_30512_193969# VSS ppolyf_u r_width=2u r_length=2u
X32 ESD_RAIL a_2245_90628# VSS VSS nfet_06v0 ad=13p pd=50.52u as=13p ps=50.52u w=50u l=0.7u
X33 ESD_RAIL a_1852_148519# VSS VSS nfet_06v0 ad=13.936p pd=54.12u as=13.936p ps=54.12u w=53.6u l=0.7u
X34 TERM_VCM TERM_TRIM3 a_26816_193969# VSS nfet_06v0 ad=5.28p pd=24.88u as=5.28p ps=24.88u w=12u l=0.7u
X35 VSS a_2245_90628# ESD_RAIL VSS nfet_06v0 ad=13p pd=50.52u as=22p ps=0.10088m w=50u l=0.7u
X36 VSS a_1852_148519# ESD_RAIL VSS nfet_06v0 ad=13.936p pd=54.12u as=13.936p ps=54.12u w=53.6u l=0.7u
X37 VSS a_2245_90628# ESD_RAIL VSS nfet_06v0 ad=13p pd=50.52u as=13p ps=50.52u w=50u l=0.7u
X38 VSS a_1852_148519# ESD_RAIL VSS nfet_06v0 ad=13.936p pd=54.12u as=13.936p ps=54.12u w=53.6u l=0.7u
X39 VSS a_1852_148519# ESD_RAIL VSS nfet_06v0 ad=23.584p pd=0.10808m as=13.936p ps=54.12u w=53.6u l=0.7u
X40 PAD_P a_50224_193864# VSS ppolyf_u r_width=2u r_length=3.05u
X41 VSS a_1852_148519# ESD_RAIL VSS nfet_06v0 ad=23.584p pd=0.10808m as=13.936p ps=54.12u w=53.6u l=0.7u
X42 VSS a_1852_148519# ESD_RAIL VSS nfet_06v0 ad=13.936p pd=54.12u as=13.936p ps=54.12u w=53.6u l=0.7u
X43 VSS a_2245_90628# ESD_RAIL VSS nfet_06v0 ad=13p pd=50.52u as=13p ps=50.52u w=50u l=0.7u
X44 ESD_RAIL a_1852_148519# VSS VSS nfet_06v0 ad=13.936p pd=54.12u as=13.936p ps=54.12u w=53.6u l=0.7u
X45 ESD_RAIL a_2245_90628# VSS VSS nfet_06v0 ad=13p pd=50.52u as=13p ps=50.52u w=50u l=0.7u
X46 ESD_RAIL a_1852_148519# VSS VSS nfet_06v0 ad=13.936p pd=54.12u as=13.936p ps=54.12u w=53.6u l=0.7u
D2 PAD_N ESD_RAIL diode_pd2nw_06v0 pj=51.8u area=22.5p
X47 VSS a_1852_148519# ESD_RAIL VSS nfet_06v0 ad=13.936p pd=54.12u as=13.936p ps=54.12u w=53.6u l=0.7u
X48 TERM_VCM TERM_TRIM3 a_30512_193969# VSS nfet_06v0 ad=5.28p pd=24.88u as=5.28p ps=24.88u w=12u l=0.7u
X49 VSS a_1852_148519# ESD_RAIL VSS nfet_06v0 ad=13.936p pd=54.12u as=13.936p ps=54.12u w=53.6u l=0.7u
X50 TERM_VCM TERM_TRIM2 a_40368_193969# VSS nfet_06v0 ad=5.28p pd=24.88u as=5.28p ps=24.88u w=12u l=0.7u
X51 ESD_RAIL a_1852_148519# VSS VSS nfet_06v0 ad=13.936p pd=54.12u as=13.936p ps=54.12u w=53.6u l=0.7u
X52 ESD_RAIL a_1852_148519# VSS VSS nfet_06v0 ad=13.936p pd=54.12u as=13.936p ps=54.12u w=53.6u l=0.7u
X53 ESD_RAIL a_1852_148519# VSS VSS nfet_06v0 ad=13.936p pd=54.12u as=13.936p ps=54.12u w=53.6u l=0.7u
X54 a_68808_187204# TERM_ENABLE TERM_VCM VSS nfet_06v0 ad=8.8p pd=40.88u as=8.8p ps=40.88u w=20u l=0.7u
X55 VSS a_1852_148519# ESD_RAIL VSS nfet_06v0 ad=13.936p pd=54.12u as=13.936p ps=54.12u w=53.6u l=0.7u
X56 VSS a_1852_148519# ESD_RAIL VSS nfet_06v0 ad=23.584p pd=0.10808m as=13.936p ps=54.12u w=53.6u l=0.7u
X57 VSS a_1852_148519# ESD_RAIL VSS nfet_06v0 ad=13.936p pd=54.12u as=13.936p ps=54.12u w=53.6u l=0.7u
X58 a_77352_188004# TERM_TRIM1 TERM_VCM VSS nfet_06v0 ad=5.28p pd=24.88u as=5.28p ps=24.88u w=12u l=0.7u
X59 ESD_RAIL a_1852_148519# VSS VSS nfet_06v0 ad=13.936p pd=54.12u as=13.936p ps=54.12u w=53.6u l=0.7u
X60 ESD_RAIL a_2245_90628# VSS VSS nfet_06v0 ad=13p pd=50.52u as=13p ps=50.52u w=50u l=0.7u
X61 ESD_RAIL a_1005_131545# a_3813_117064# ESD_RAIL pfet_06v0 ad=1.3p pd=5.52u as=1.3p ps=5.52u w=5u l=0.7u
D3 VSS PAD_P diode_nd2ps_06v0 pj=51.8u area=22.5p
D4 PAD_N ESD_RAIL diode_pd2nw_06v0 pj=51.8u area=22.5p
X62 w_53184_209128# w_53184_209128# VDD w_53184_209128# pfet_06v0 ad=1.76p pd=8.88u as=1.76p ps=8.88u w=4u l=0.55u
X63 ESD_RAIL a_1852_148519# VSS VSS nfet_06v0 ad=13.936p pd=54.12u as=13.936p ps=54.12u w=53.6u l=0.7u
X64 ESD_RAIL a_1852_148519# VSS VSS nfet_06v0 ad=13.936p pd=54.12u as=13.936p ps=54.12u w=53.6u l=0.7u
X65 PAD_N a_69876_187204# VSS ppolyf_u r_width=2u r_length=3.05u
X66 VSS a_1852_148519# ESD_RAIL VSS nfet_06v0 ad=13.936p pd=54.12u as=13.936p ps=54.12u w=53.6u l=0.7u
X67 RX_P PAD_P cap_mim_2f0_m4m5_noshield c_width=35u c_length=35u
X68 PAD_N a_68808_187204# VSS ppolyf_u r_width=2u r_length=3.05u
X69 VSS a_1852_148519# ESD_RAIL VSS nfet_06v0 ad=13.936p pd=54.12u as=13.936p ps=54.12u w=53.6u l=0.7u
X70 ESD_RAIL a_1852_148519# VSS VSS nfet_06v0 ad=13.936p pd=54.12u as=13.936p ps=54.12u w=53.6u l=0.7u
X71 TERM_VCM TERM_TRIM1 a_41600_193969# VSS nfet_06v0 ad=5.28p pd=24.88u as=5.28p ps=24.88u w=12u l=0.7u
X72 ESD_RAIL a_1852_148519# VSS VSS nfet_06v0 ad=13.936p pd=54.12u as=13.936p ps=54.12u w=53.6u l=0.7u
X73 VSS a_2245_90628# ESD_RAIL VSS nfet_06v0 ad=13p pd=50.52u as=13p ps=50.52u w=50u l=0.7u
X74 TERM_VCM TERM_TRIM2 a_39136_193969# VSS nfet_06v0 ad=5.28p pd=24.88u as=5.28p ps=24.88u w=12u l=0.7u
D5 PAD_N ESD_RAIL diode_pd2nw_06v0 pj=51.8u area=22.5p
X75 VSS a_2245_90628# ESD_RAIL VSS nfet_06v0 ad=13p pd=50.52u as=13p ps=50.52u w=50u l=0.7u
X76 VSS a_2245_90628# ESD_RAIL VSS nfet_06v0 ad=13p pd=50.52u as=13p ps=50.52u w=50u l=0.7u
X77 VSS a_1852_148519# ESD_RAIL VSS nfet_06v0 ad=13.936p pd=54.12u as=13.936p ps=54.12u w=53.6u l=0.7u
X78 TERM_VCM TERM_ENABLE a_45296_193864# VSS nfet_06v0 ad=8.8p pd=40.88u as=8.8p ps=40.88u w=20u l=0.7u
X79 ESD_RAIL a_1852_148519# VSS VSS nfet_06v0 ad=13.936p pd=54.12u as=13.936p ps=54.12u w=53.6u l=0.7u
X80 VSS a_1852_148519# ESD_RAIL VSS nfet_06v0 ad=13.936p pd=54.12u as=13.936p ps=54.12u w=53.6u l=0.7u
X81 a_78420_188004# TERM_TRIM1 TERM_VCM VSS nfet_06v0 ad=5.28p pd=24.88u as=5.28p ps=24.88u w=12u l=0.7u
X82 ESD_RAIL a_2245_90628# VSS VSS nfet_06v0 ad=13p pd=50.52u as=13p ps=50.52u w=50u l=0.7u
X83 VSS a_1852_148519# ESD_RAIL VSS nfet_06v0 ad=13.936p pd=54.12u as=13.936p ps=54.12u w=53.6u l=0.7u
X84 ESD_RAIL a_1852_148519# VSS VSS nfet_06v0 ad=13.936p pd=54.12u as=13.936p ps=54.12u w=53.6u l=0.7u
X85 ESD_RAIL a_1852_148519# VSS VSS nfet_06v0 ad=13.936p pd=54.12u as=13.936p ps=54.12u w=53.6u l=0.7u
X86 a_76284_188004# TERM_TRIM0 TERM_VCM VSS nfet_06v0 ad=5.28p pd=24.88u as=5.28p ps=24.88u w=12u l=0.7u
X87 ESD_RAIL a_2245_90628# VSS VSS nfet_06v0 ad=13p pd=50.52u as=13p ps=50.52u w=50u l=0.7u
X88 ESD_RAIL a_2245_90628# VSS VSS nfet_06v0 ad=13p pd=50.52u as=13p ps=50.52u w=50u l=0.7u
X89 a_2245_90628# a_4789_117064# ESD_RAIL ESD_RAIL pfet_06v0 ad=1.3p pd=5.52u as=1.3p ps=5.52u w=5u l=0.7u
X90 PAD_P a_29280_193969# VSS ppolyf_u r_width=2u r_length=2u
X91 ESD_RAIL a_1852_148519# VSS VSS nfet_06v0 ad=13.936p pd=54.12u as=23.584p ps=0.10808m w=53.6u l=0.7u
X92 ESD_RAIL a_1852_148519# VSS VSS nfet_06v0 ad=13.936p pd=54.12u as=13.936p ps=54.12u w=53.6u l=0.7u
X93 VDD w_53184_209128# w_53184_209128# w_53184_209128# pfet_06v0 ad=1.76p pd=8.88u as=1.76p ps=8.88u w=4u l=0.55u
D6 PAD_N ESD_RAIL diode_pd2nw_06v0 pj=51.8u area=22.5p
X94 ESD_RAIL a_1852_148519# VSS VSS nfet_06v0 ad=13.936p pd=54.12u as=13.936p ps=54.12u w=53.6u l=0.7u
X95 a_2245_90628# a_4789_117064# ESD_RAIL ESD_RAIL pfet_06v0 ad=1.3p pd=5.52u as=1.3p ps=5.52u w=5u l=0.7u
X96 VSS a_1852_148519# ESD_RAIL VSS nfet_06v0 ad=13.936p pd=54.12u as=13.936p ps=54.12u w=53.6u l=0.7u
X97 ESD_RAIL a_2245_90628# VSS VSS nfet_06v0 ad=13p pd=50.52u as=13p ps=50.52u w=50u l=0.7u
X98 VSS a_1852_148519# ESD_RAIL VSS nfet_06v0 ad=13.936p pd=54.12u as=13.936p ps=54.12u w=53.6u l=0.7u
X99 PAD_N a_85896_188004# VSS ppolyf_u r_width=2u r_length=2u
X100 RX_N PAD_N cap_mim_2f0_m4m5_noshield c_width=35u c_length=35u
X101 ESD_RAIL a_4789_117064# a_2245_90628# ESD_RAIL pfet_06v0 ad=1.3p pd=5.52u as=1.3p ps=5.52u w=5u l=0.7u
X102 a_1005_132385# a_13878_132105# ESD_RAIL ppolyf_u r_width=0.8u r_length=63.855u
X103 ESD_RAIL a_1852_148519# VSS VSS nfet_06v0 ad=13.936p pd=54.12u as=13.936p ps=54.12u w=53.6u l=0.7u
X104 ESD_RAIL w_53184_209128# VSS ppolyf_u_1k_6p0 r_width=1u r_length=0.47474m
X105 PAD_N a_77352_188004# VSS ppolyf_u r_width=2u r_length=2u
X106 ESD_RAIL a_1852_148519# VSS VSS nfet_06v0 ad=13.936p pd=54.12u as=13.936p ps=54.12u w=53.6u l=0.7u
X107 TERM_VCM TERM_TRIM2 a_37904_193969# VSS nfet_06v0 ad=5.28p pd=24.88u as=5.28p ps=24.88u w=12u l=0.7u
X108 VSS a_2245_90628# ESD_RAIL VSS nfet_06v0 ad=13p pd=50.52u as=13p ps=50.52u w=50u l=0.7u
X109 VSS a_1852_148519# ESD_RAIL VSS nfet_06v0 ad=13.936p pd=54.12u as=13.936p ps=54.12u w=53.6u l=0.7u
X110 VSS a_1852_148519# ESD_RAIL VSS nfet_06v0 ad=13.936p pd=54.12u as=13.936p ps=54.12u w=53.6u l=0.7u
X111 VSS a_1852_148519# ESD_RAIL VSS nfet_06v0 ad=13.936p pd=54.12u as=13.936p ps=54.12u w=53.6u l=0.7u
X112 ESD_RAIL a_4789_117064# a_2245_90628# ESD_RAIL pfet_06v0 ad=1.3p pd=5.52u as=1.3p ps=5.52u w=5u l=0.7u
X113 RX_N VSS VSS VSS nfet_06v0 ad=1.76p pd=8.88u as=1.76p ps=8.88u w=4u l=0.7u
X114 a_2245_90628# a_4789_117064# VSS VSS nfet_06v0 ad=1.3p pd=5.52u as=1.3p ps=5.52u w=5u l=0.7u
X115 ESD_RAIL a_1852_148519# VSS VSS nfet_06v0 ad=13.936p pd=54.12u as=13.936p ps=54.12u w=53.6u l=0.7u
X116 a_2245_90628# a_4789_117064# ESD_RAIL ESD_RAIL pfet_06v0 ad=1.3p pd=5.52u as=1.3p ps=5.52u w=5u l=0.7u
X117 ESD_RAIL a_1005_131545# a_3813_117064# ESD_RAIL pfet_06v0 ad=1.3p pd=5.52u as=1.3p ps=5.52u w=5u l=0.7u
X118 ESD_RAIL a_1852_148519# VSS VSS nfet_06v0 ad=13.936p pd=54.12u as=13.936p ps=54.12u w=53.6u l=0.7u
X119 VSS a_1852_148519# ESD_RAIL VSS nfet_06v0 ad=13.936p pd=54.12u as=13.936p ps=54.12u w=53.6u l=0.7u
X120 VSS a_1852_148519# ESD_RAIL VSS nfet_06v0 ad=13.936p pd=54.12u as=13.936p ps=54.12u w=53.6u l=0.7u
X121 a_83760_188004# TERM_TRIM3 TERM_VCM VSS nfet_06v0 ad=5.28p pd=24.88u as=5.28p ps=24.88u w=12u l=0.7u
X122 VSS a_2245_90628# ESD_RAIL VSS nfet_06v0 ad=13p pd=50.52u as=13p ps=50.52u w=50u l=0.7u
X123 ESD_RAIL a_1852_148519# VSS VSS nfet_06v0 ad=13.936p pd=54.12u as=23.584p ps=0.10808m w=53.6u l=0.7u
X124 ESD_RAIL a_1852_148519# VSS VSS nfet_06v0 ad=13.936p pd=54.12u as=13.936p ps=54.12u w=53.6u l=0.7u
X125 ESD_RAIL a_1852_148519# VSS VSS nfet_06v0 ad=13.936p pd=54.12u as=23.584p ps=0.10808m w=53.6u l=0.7u
X126 a_2245_90628# a_4789_117064# ESD_RAIL ESD_RAIL pfet_06v0 ad=1.3p pd=5.52u as=1.3p ps=5.52u w=5u l=0.7u
X127 VSS a_1852_148519# ESD_RAIL VSS nfet_06v0 ad=23.584p pd=0.10808m as=13.936p ps=54.12u w=53.6u l=0.7u
X128 TERM_VCM TERM_ENABLE a_55152_193864# VSS nfet_06v0 ad=8.8p pd=40.88u as=8.8p ps=40.88u w=20u l=0.7u
X129 VSS a_1852_148519# ESD_RAIL VSS nfet_06v0 ad=13.936p pd=54.12u as=13.936p ps=54.12u w=53.6u l=0.7u
X130 VSS a_1852_148519# ESD_RAIL VSS nfet_06v0 ad=13.936p pd=54.12u as=13.936p ps=54.12u w=53.6u l=0.7u
X131 ESD_RAIL a_2245_90628# VSS VSS nfet_06v0 ad=13p pd=50.52u as=13p ps=50.52u w=50u l=0.7u
X132 PAD_N a_79488_188004# VSS ppolyf_u r_width=2u r_length=2u
X133 a_1005_131545# VSS cap_mim_2f0_m4m5_noshield c_width=14u c_length=14u
X134 ESD_RAIL a_2245_90628# VSS VSS nfet_06v0 ad=13p pd=50.52u as=13p ps=50.52u w=50u l=0.7u
X135 ESD_RAIL a_1852_148519# VSS VSS nfet_06v0 ad=13.936p pd=54.12u as=13.936p ps=54.12u w=53.6u l=0.7u
X136 VSS a_1852_148519# ESD_RAIL VSS nfet_06v0 ad=13.936p pd=54.12u as=13.936p ps=54.12u w=53.6u l=0.7u
X137 ESD_RAIL a_1852_148519# VSS VSS nfet_06v0 ad=13.936p pd=54.12u as=13.936p ps=54.12u w=53.6u l=0.7u
X138 RX_P PAD_P cap_mim_2f0_m4m5_noshield c_width=35u c_length=35u
X139 a_1005_131825# a_13878_132105# ESD_RAIL ppolyf_u r_width=0.8u r_length=63.855u
D7 PAD_P ESD_RAIL diode_pd2nw_06v0 pj=51.8u area=22.5p
X140 VSS a_1852_148519# ESD_RAIL VSS nfet_06v0 ad=23.584p pd=0.10808m as=13.936p ps=54.12u w=53.6u l=0.7u
X141 ESD_RAIL a_2245_90628# VSS VSS nfet_06v0 ad=13p pd=50.52u as=13p ps=50.52u w=50u l=0.7u
X142 ESD_RAIL a_2245_90628# VSS VSS nfet_06v0 ad=13p pd=50.52u as=13p ps=50.52u w=50u l=0.7u
X143 PAD_N a_65416_193864# VSS ppolyf_u r_width=2u r_length=3.05u
X144 a_2245_90628# a_4789_117064# ESD_RAIL ESD_RAIL pfet_06v0 ad=1.3p pd=5.52u as=1.3p ps=5.52u w=5u l=0.7u
X145 ESD_RAIL a_2245_90628# VSS VSS nfet_06v0 ad=13p pd=50.52u as=13p ps=50.52u w=50u l=0.7u
X146 VSS a_2245_90628# ESD_RAIL VSS nfet_06v0 ad=13p pd=50.52u as=13p ps=50.52u w=50u l=0.7u
X147 VSS a_1852_148519# ESD_RAIL VSS nfet_06v0 ad=13.936p pd=54.12u as=13.936p ps=54.12u w=53.6u l=0.7u
X148 a_82692_188004# TERM_TRIM2 TERM_VCM VSS nfet_06v0 ad=5.28p pd=24.88u as=5.28p ps=24.88u w=12u l=0.7u
X149 VSS a_2245_90628# ESD_RAIL VSS nfet_06v0 ad=13p pd=50.52u as=13p ps=50.52u w=50u l=0.7u
X150 ESD_RAIL a_1852_148519# VSS VSS nfet_06v0 ad=13.936p pd=54.12u as=13.936p ps=54.12u w=53.6u l=0.7u
X151 ESD_RAIL a_1852_148519# VSS VSS nfet_06v0 ad=13.936p pd=54.12u as=13.936p ps=54.12u w=53.6u l=0.7u
X152 VBIAS RX_P VSS ppolyf_u_1k r_width=1u r_length=40u
X153 TERM_VCM TERM_ENABLE a_56384_193864# VSS nfet_06v0 ad=8.8p pd=40.88u as=8.8p ps=40.88u w=20u l=0.7u
X154 a_2245_90628# a_4789_117064# ESD_RAIL ESD_RAIL pfet_06v0 ad=1.3p pd=5.52u as=1.3p ps=5.52u w=5u l=0.7u
X155 a_80556_188004# TERM_TRIM2 TERM_VCM VSS nfet_06v0 ad=5.28p pd=24.88u as=5.28p ps=24.88u w=12u l=0.7u
X156 VSS a_4789_117064# a_2245_90628# VSS nfet_06v0 ad=2.2p pd=10.88u as=1.3p ps=5.52u w=5u l=0.7u
X157 VSS a_1852_148519# ESD_RAIL VSS nfet_06v0 ad=13.936p pd=54.12u as=13.936p ps=54.12u w=53.6u l=0.7u
X158 ESD_RAIL a_4789_117064# a_2245_90628# ESD_RAIL pfet_06v0 ad=1.3p pd=5.52u as=1.3p ps=5.52u w=5u l=0.7u
X159 ESD_RAIL a_2245_90628# VSS VSS nfet_06v0 ad=22p pd=0.10088m as=13p ps=50.52u w=50u l=0.7u
D8 VSS PAD_N diode_nd2ps_06v0 pj=51.8u area=22.5p
X160 PAD_P a_35440_193969# VSS ppolyf_u r_width=2u r_length=2u
X161 a_1005_132945# a_13878_133225# ESD_RAIL ppolyf_u r_width=0.8u r_length=63.855u
X162 ESD_RAIL a_1852_148519# VSS VSS nfet_06v0 ad=13.936p pd=54.12u as=13.936p ps=54.12u w=53.6u l=0.7u
X163 ESD_RAIL a_1852_148519# VSS VSS nfet_06v0 ad=13.936p pd=54.12u as=13.936p ps=54.12u w=53.6u l=0.7u
X164 ESD_RAIL a_1852_148519# VSS VSS nfet_06v0 ad=13.936p pd=54.12u as=13.936p ps=54.12u w=53.6u l=0.7u
X165 VSS a_1852_148519# ESD_RAIL VSS nfet_06v0 ad=13.936p pd=54.12u as=13.936p ps=54.12u w=53.6u l=0.7u
X166 ESD_RAIL a_4789_117064# a_2245_90628# ESD_RAIL pfet_06v0 ad=1.3p pd=5.52u as=1.3p ps=5.52u w=5u l=0.7u
X167 a_2245_90628# a_4789_117064# VSS VSS nfet_06v0 ad=1.3p pd=5.52u as=1.3p ps=5.52u w=5u l=0.7u
X168 ESD_RAIL a_1852_148519# VSS VSS nfet_06v0 ad=13.936p pd=54.12u as=13.936p ps=54.12u w=53.6u l=0.7u
X169 PAD_P a_55152_193864# VSS ppolyf_u r_width=2u r_length=3.05u
X170 a_2245_90628# a_4789_117064# ESD_RAIL ESD_RAIL pfet_06v0 ad=1.3p pd=5.52u as=2.2p ps=10.88u w=5u l=0.7u
X171 a_3813_117064# a_1005_131545# VSS VSS nfet_06v0 ad=2.2p pd=10.88u as=2.2p ps=10.88u w=5u l=0.7u
X172 PAD_P a_45296_193864# VSS ppolyf_u r_width=2u r_length=3.05u
X173 VSS a_1852_148519# ESD_RAIL VSS nfet_06v0 ad=13.936p pd=54.12u as=13.936p ps=54.12u w=53.6u l=0.7u
D9 PAD_P ESD_RAIL diode_pd2nw_06v0 pj=51.8u area=22.5p
X174 VSS a_1852_148519# ESD_RAIL VSS nfet_06v0 ad=13.936p pd=54.12u as=13.936p ps=54.12u w=53.6u l=0.7u
X175 VSS a_1852_148519# ESD_RAIL VSS nfet_06v0 ad=13.936p pd=54.12u as=13.936p ps=54.12u w=53.6u l=0.7u
X176 VSS a_1852_148519# ESD_RAIL VSS nfet_06v0 ad=13.936p pd=54.12u as=13.936p ps=54.12u w=53.6u l=0.7u
X177 ESD_RAIL a_2245_90628# VSS VSS nfet_06v0 ad=13p pd=50.52u as=13p ps=50.52u w=50u l=0.7u
X178 a_2245_90628# a_4789_117064# VSS VSS nfet_06v0 ad=1.3p pd=5.52u as=1.3p ps=5.52u w=5u l=0.7u
X179 VSS a_3813_117064# a_4789_117064# VSS nfet_06v0 ad=1.3p pd=5.52u as=1.3p ps=5.52u w=5u l=0.7u
X180 a_2245_90628# a_4789_117064# ESD_RAIL ESD_RAIL pfet_06v0 ad=1.3p pd=5.52u as=1.3p ps=5.52u w=5u l=0.7u
X181 VSS a_1852_148519# ESD_RAIL VSS nfet_06v0 ad=13.936p pd=54.12u as=13.936p ps=54.12u w=53.6u l=0.7u
X182 ESD_RAIL a_1852_148519# VSS VSS nfet_06v0 ad=13.936p pd=54.12u as=13.936p ps=54.12u w=53.6u l=0.7u
X183 a_81624_188004# TERM_TRIM2 TERM_VCM VSS nfet_06v0 ad=5.28p pd=24.88u as=5.28p ps=24.88u w=12u l=0.7u
X184 a_1005_134065# a_13878_134345# ESD_RAIL ppolyf_u r_width=0.8u r_length=63.855u
X185 ESD_RAIL a_2245_90628# VSS VSS nfet_06v0 ad=13p pd=50.52u as=13p ps=50.52u w=50u l=0.7u
X186 ESD_RAIL a_1852_148519# VSS VSS nfet_06v0 ad=13.936p pd=54.12u as=13.936p ps=54.12u w=53.6u l=0.7u
X187 PAD_P a_47760_193864# VSS ppolyf_u r_width=2u r_length=3.05u
X188 ESD_RAIL a_2245_90628# VSS VSS nfet_06v0 ad=13p pd=50.52u as=13p ps=50.52u w=50u l=0.7u
X189 VSS a_3813_117064# a_4789_117064# VSS nfet_06v0 ad=1.3p pd=5.52u as=1.3p ps=5.52u w=5u l=0.7u
D10 PAD_P ESD_RAIL diode_pd2nw_06v0 pj=51.8u area=22.5p
X190 VSS a_1852_148519# ESD_RAIL VSS nfet_06v0 ad=13.936p pd=54.12u as=13.936p ps=54.12u w=53.6u l=0.7u
X191 ESD_RAIL a_1852_148519# VSS VSS nfet_06v0 ad=13.936p pd=54.12u as=13.936p ps=54.12u w=53.6u l=0.7u
X192 TERM_VCM TERM_TRIM3 a_29280_193969# VSS nfet_06v0 ad=5.28p pd=24.88u as=5.28p ps=24.88u w=12u l=0.7u
X193 VSS a_2245_90628# ESD_RAIL VSS nfet_06v0 ad=13p pd=50.52u as=13p ps=50.52u w=50u l=0.7u
X194 PAD_N a_74148_187204# VSS ppolyf_u r_width=2u r_length=3.05u
X195 VSS a_1852_148519# ESD_RAIL VSS nfet_06v0 ad=13.936p pd=54.12u as=13.936p ps=54.12u w=53.6u l=0.7u
X196 ESD_RAIL a_2245_90628# VSS VSS nfet_06v0 ad=13p pd=50.52u as=13p ps=50.52u w=50u l=0.7u
X197 a_67740_187204# TERM_ENABLE TERM_VCM VSS nfet_06v0 ad=8.8p pd=40.88u as=8.8p ps=40.88u w=20u l=0.7u
X198 VDD VDD RX_P VDD pfet_06v0 ad=1.76p pd=8.88u as=1.76p ps=8.88u w=4u l=0.55u
X199 ESD_RAIL a_1852_148519# VSS VSS nfet_06v0 ad=13.936p pd=54.12u as=13.936p ps=54.12u w=53.6u l=0.7u
X200 VSS a_1852_148519# ESD_RAIL VSS nfet_06v0 ad=13.936p pd=54.12u as=13.936p ps=54.12u w=53.6u l=0.7u
D11 VSS PAD_N diode_nd2ps_06v0 pj=51.8u area=22.5p
X201 VSS a_1852_148519# ESD_RAIL VSS nfet_06v0 ad=13.936p pd=54.12u as=13.936p ps=54.12u w=53.6u l=0.7u
X202 ESD_RAIL a_1852_148519# VSS VSS nfet_06v0 ad=13.936p pd=54.12u as=13.936p ps=54.12u w=53.6u l=0.7u
X203 a_2245_90628# a_4789_117064# ESD_RAIL ESD_RAIL pfet_06v0 ad=1.3p pd=5.52u as=1.3p ps=5.52u w=5u l=0.7u
X204 VSS VSS RX_P VSS nfet_06v0 ad=1.76p pd=8.88u as=1.76p ps=8.88u w=4u l=0.7u
X205 PAD_N a_67740_187204# VSS ppolyf_u r_width=2u r_length=3.05u
X206 VSS a_1852_148519# ESD_RAIL VSS nfet_06v0 ad=23.584p pd=0.10808m as=13.936p ps=54.12u w=53.6u l=0.7u
X207 ESD_RAIL a_2245_90628# VSS VSS nfet_06v0 ad=13p pd=50.52u as=13p ps=50.52u w=50u l=0.7u
X208 VSS a_1852_148519# ESD_RAIL VSS nfet_06v0 ad=13.936p pd=54.12u as=13.936p ps=54.12u w=53.6u l=0.7u
X209 VSS a_1852_148519# ESD_RAIL VSS nfet_06v0 ad=13.936p pd=54.12u as=13.936p ps=54.12u w=53.6u l=0.7u
X210 VSS a_1852_148519# ESD_RAIL VSS nfet_06v0 ad=13.936p pd=54.12u as=13.936p ps=54.12u w=53.6u l=0.7u
X211 VSS a_2245_90628# ESD_RAIL VSS nfet_06v0 ad=13p pd=50.52u as=13p ps=50.52u w=50u l=0.7u
X212 TERM_VCM TERM_TRIM3 a_28048_193969# VSS nfet_06v0 ad=5.28p pd=24.88u as=5.28p ps=24.88u w=12u l=0.7u
X213 PAD_P a_28048_193969# VSS ppolyf_u r_width=2u r_length=2u
D12 PAD_P ESD_RAIL diode_pd2nw_06v0 pj=51.8u area=22.5p
X214 ESD_RAIL a_2245_90628# VSS VSS nfet_06v0 ad=13p pd=50.52u as=13p ps=50.52u w=50u l=0.7u
X215 PAD_N a_91236_188004# VSS ppolyf_u r_width=2u r_length=2u
X216 a_90168_188004# TERM_TRIM3 TERM_VCM VSS nfet_06v0 ad=5.28p pd=24.88u as=5.28p ps=24.88u w=12u l=0.7u
X217 VSS a_1852_148519# ESD_RAIL VSS nfet_06v0 ad=23.584p pd=0.10808m as=13.936p ps=54.12u w=53.6u l=0.7u
X218 PAD_P a_41600_193969# VSS ppolyf_u r_width=2u r_length=2u
X219 a_66648_193864# TERM_ENABLE TERM_VCM VSS nfet_06v0 ad=8.8p pd=40.88u as=8.8p ps=40.88u w=20u l=0.7u
X220 VSS a_1852_148519# ESD_RAIL VSS nfet_06v0 ad=23.584p pd=0.10808m as=13.936p ps=54.12u w=53.6u l=0.7u
X221 ESD_RAIL a_1852_148519# VSS VSS nfet_06v0 ad=13.936p pd=54.12u as=13.936p ps=54.12u w=53.6u l=0.7u
X222 ESD_RAIL a_1852_148519# VSS VSS nfet_06v0 ad=13.936p pd=54.12u as=13.936p ps=54.12u w=53.6u l=0.7u
X223 PAD_P a_31744_193969# VSS ppolyf_u r_width=2u r_length=2u
X224 VSS a_2245_90628# ESD_RAIL VSS nfet_06v0 ad=13p pd=50.52u as=13p ps=50.52u w=50u l=0.7u
X225 VSS a_1852_148519# ESD_RAIL VSS nfet_06v0 ad=13.936p pd=54.12u as=13.936p ps=54.12u w=53.6u l=0.7u
X226 VSS a_1852_148519# ESD_RAIL VSS nfet_06v0 ad=13.936p pd=54.12u as=13.936p ps=54.12u w=53.6u l=0.7u
X227 TERM_VCM TERM_ENABLE a_47760_193864# VSS nfet_06v0 ad=8.8p pd=40.88u as=8.8p ps=40.88u w=20u l=0.7u
X228 ESD_RAIL a_1852_148519# VSS VSS nfet_06v0 ad=13.936p pd=54.12u as=13.936p ps=54.12u w=53.6u l=0.7u
X229 PAD_P a_51456_193864# VSS ppolyf_u r_width=2u r_length=3.05u
X230 ESD_RAIL a_1852_148519# VSS VSS nfet_06v0 ad=13.936p pd=54.12u as=13.936p ps=54.12u w=53.6u l=0.7u
X231 VSS a_1852_148519# ESD_RAIL VSS nfet_06v0 ad=13.936p pd=54.12u as=13.936p ps=54.12u w=53.6u l=0.7u
X232 ESD_RAIL a_2245_90628# VSS VSS nfet_06v0 ad=13p pd=50.52u as=13p ps=50.52u w=50u l=0.7u
X233 VSS a_1852_148519# ESD_RAIL VSS nfet_06v0 ad=13.936p pd=54.12u as=13.936p ps=54.12u w=53.6u l=0.7u
D13 PAD_N ESD_RAIL diode_pd2nw_06v0 pj=51.8u area=22.5p
X234 a_91236_188004# TERM_TRIM3 TERM_VCM VSS nfet_06v0 ad=5.28p pd=24.88u as=5.28p ps=24.88u w=12u l=0.7u
X235 PAD_P a_53920_193864# VSS ppolyf_u r_width=2u r_length=3.05u
X236 ESD_RAIL a_2245_90628# VSS VSS nfet_06v0 ad=13p pd=50.52u as=13p ps=50.52u w=50u l=0.7u
X237 ESD_RAIL a_2245_90628# VSS VSS nfet_06v0 ad=13p pd=50.52u as=13p ps=50.52u w=50u l=0.7u
D14 VSS ESD_RAIL diode_nd2ps_06v0 pj=82u area=40p
X238 ESD_RAIL a_1852_148519# VSS VSS nfet_06v0 ad=13.936p pd=54.12u as=13.936p ps=54.12u w=53.6u l=0.7u
X239 a_4789_117064# a_3813_117064# VSS VSS nfet_06v0 ad=1.3p pd=5.52u as=2.2p ps=10.88u w=5u l=0.7u
X240 ESD_RAIL a_1852_148519# VSS VSS nfet_06v0 ad=13.936p pd=54.12u as=13.936p ps=54.12u w=53.6u l=0.7u
X241 a_65416_193864# TERM_ENABLE TERM_VCM VSS nfet_06v0 ad=8.8p pd=40.88u as=8.8p ps=40.88u w=20u l=0.7u
X242 ESD_RAIL a_2245_90628# VSS VSS nfet_06v0 ad=13p pd=50.52u as=13p ps=50.52u w=50u l=0.7u
X243 PAD_N a_83760_188004# VSS ppolyf_u r_width=2u r_length=2u
D15 VSS ESD_RAIL diode_nd2ps_06v0 pj=82u area=40p
X244 VSS a_2245_90628# ESD_RAIL VSS nfet_06v0 ad=13p pd=50.52u as=13p ps=50.52u w=50u l=0.7u
X245 VSS a_1852_148519# ESD_RAIL VSS nfet_06v0 ad=13.936p pd=54.12u as=13.936p ps=54.12u w=53.6u l=0.7u
X246 RX_N PAD_N cap_mim_2f0_m4m5_noshield c_width=35u c_length=35u
X247 TERM_VCM TERM_ENABLE a_46528_193864# VSS nfet_06v0 ad=8.8p pd=40.88u as=8.8p ps=40.88u w=20u l=0.7u
X248 PAD_N a_70944_187204# VSS ppolyf_u r_width=2u r_length=3.05u
D16 PAD_N ESD_RAIL diode_pd2nw_06v0 pj=51.8u area=22.5p
X249 ESD_RAIL a_1852_148519# cap_mim_2f0_m4m5_noshield c_width=90u c_length=90u
X250 a_1005_131825# a_13878_131545# ESD_RAIL ppolyf_u r_width=0.8u r_length=63.855u
X251 ESD_RAIL a_1852_148519# VSS VSS nfet_06v0 ad=13.936p pd=54.12u as=13.936p ps=54.12u w=53.6u l=0.7u
X252 ESD_RAIL a_1852_148519# VSS VSS nfet_06v0 ad=13.936p pd=54.12u as=13.936p ps=54.12u w=53.6u l=0.7u
X253 VBIAS RX_N VSS ppolyf_u_1k r_width=1u r_length=40u
X254 ESD_RAIL VSS cap_mim_2f0_m4m5_noshield c_width=31.6u c_length=31.6u
X255 VSS a_1852_148519# ESD_RAIL VSS nfet_06v0 ad=13.936p pd=54.12u as=13.936p ps=54.12u w=53.6u l=0.7u
X256 VSS a_2245_90628# ESD_RAIL VSS nfet_06v0 ad=13p pd=50.52u as=22p ps=0.10088m w=50u l=0.7u
X257 ESD_RAIL a_1852_148519# VSS VSS nfet_06v0 ad=13.936p pd=54.12u as=13.936p ps=54.12u w=53.6u l=0.7u
D17 VSS PAD_P diode_nd2ps_06v0 pj=51.8u area=22.5p
X258 VSS a_2245_90628# ESD_RAIL VSS nfet_06v0 ad=13p pd=50.52u as=22p ps=0.10088m w=50u l=0.7u
X259 TERM_VCM TERM_TRIM2 a_36672_193969# VSS nfet_06v0 ad=5.28p pd=24.88u as=5.28p ps=24.88u w=12u l=0.7u
X260 ESD_RAIL a_4789_117064# a_2245_90628# ESD_RAIL pfet_06v0 ad=1.3p pd=5.52u as=1.3p ps=5.52u w=5u l=0.7u
X261 ESD_RAIL a_1852_148519# VSS VSS nfet_06v0 ad=13.936p pd=54.12u as=13.936p ps=54.12u w=53.6u l=0.7u
X262 ESD_RAIL a_1852_148519# VSS VSS nfet_06v0 ad=13.936p pd=54.12u as=13.936p ps=54.12u w=53.6u l=0.7u
X263 VSS a_1852_148519# ESD_RAIL VSS nfet_06v0 ad=13.936p pd=54.12u as=13.936p ps=54.12u w=53.6u l=0.7u
X264 a_73080_187204# TERM_ENABLE TERM_VCM VSS nfet_06v0 ad=8.8p pd=40.88u as=8.8p ps=40.88u w=20u l=0.7u
X265 VSS a_1852_148519# ESD_RAIL VSS nfet_06v0 ad=13.936p pd=54.12u as=13.936p ps=54.12u w=53.6u l=0.7u
X266 PAD_P a_34208_193969# VSS ppolyf_u r_width=2u r_length=2u
X267 VSS a_2245_90628# ESD_RAIL VSS nfet_06v0 ad=13p pd=50.52u as=13p ps=50.52u w=50u l=0.7u
X268 ESD_RAIL a_4789_117064# a_2245_90628# ESD_RAIL pfet_06v0 ad=1.3p pd=5.52u as=1.3p ps=5.52u w=5u l=0.7u
X269 a_70944_187204# TERM_ENABLE TERM_VCM VSS nfet_06v0 ad=8.8p pd=40.88u as=8.8p ps=40.88u w=20u l=0.7u
X270 ESD_RAIL a_2245_90628# VSS VSS nfet_06v0 ad=13p pd=50.52u as=13p ps=50.52u w=50u l=0.7u
X271 a_1005_132945# a_13878_132665# ESD_RAIL ppolyf_u r_width=0.8u r_length=63.855u
X272 ESD_RAIL a_1852_148519# VSS VSS nfet_06v0 ad=13.936p pd=54.12u as=13.936p ps=54.12u w=53.6u l=0.7u
X273 ESD_RAIL a_2245_90628# VSS VSS nfet_06v0 ad=13p pd=50.52u as=13p ps=50.52u w=50u l=0.7u
X274 ESD_RAIL a_1852_148519# VSS VSS nfet_06v0 ad=13.936p pd=54.12u as=13.936p ps=54.12u w=53.6u l=0.7u
D18 PAD_N ESD_RAIL diode_pd2nw_06v0 pj=51.8u area=22.5p
X275 VSS a_1852_148519# ESD_RAIL VSS nfet_06v0 ad=13.936p pd=54.12u as=13.936p ps=54.12u w=53.6u l=0.7u
X276 ESD_RAIL a_1852_148519# VSS VSS nfet_06v0 ad=13.936p pd=54.12u as=13.936p ps=54.12u w=53.6u l=0.7u
X277 ESD_RAIL a_1852_148519# VSS VSS nfet_06v0 ad=13.936p pd=54.12u as=13.936p ps=54.12u w=53.6u l=0.7u
X278 VSS a_1852_148519# ESD_RAIL VSS nfet_06v0 ad=23.584p pd=0.10808m as=13.936p ps=54.12u w=53.6u l=0.7u
X279 ESD_RAIL a_1852_148519# VSS VSS nfet_06v0 ad=13.936p pd=54.12u as=13.936p ps=54.12u w=53.6u l=0.7u
X280 VSS a_2245_90628# ESD_RAIL VSS nfet_06v0 ad=13p pd=50.52u as=13p ps=50.52u w=50u l=0.7u
X281 a_74148_187204# TERM_ENABLE TERM_VCM VSS nfet_06v0 ad=8.8p pd=40.88u as=8.8p ps=40.88u w=20u l=0.7u
X282 VSS a_1852_148519# ESD_RAIL VSS nfet_06v0 ad=13.936p pd=54.12u as=13.936p ps=54.12u w=53.6u l=0.7u
X283 VSS a_1852_148519# ESD_RAIL VSS nfet_06v0 ad=13.936p pd=54.12u as=13.936p ps=54.12u w=53.6u l=0.7u
X284 VSS a_1852_148519# ESD_RAIL VSS nfet_06v0 ad=13.936p pd=54.12u as=13.936p ps=54.12u w=53.6u l=0.7u
X285 VSS a_1852_148519# ESD_RAIL VSS nfet_06v0 ad=13.936p pd=54.12u as=13.936p ps=54.12u w=53.6u l=0.7u
X286 VSS a_1852_148519# ESD_RAIL VSS nfet_06v0 ad=13.936p pd=54.12u as=13.936p ps=54.12u w=53.6u l=0.7u
X287 ESD_RAIL a_1852_148519# VSS VSS nfet_06v0 ad=13.936p pd=54.12u as=13.936p ps=54.12u w=53.6u l=0.7u
X288 PAD_P a_26816_193969# VSS ppolyf_u r_width=2u r_length=2u
X289 a_3813_117064# a_1005_131545# ESD_RAIL ESD_RAIL pfet_06v0 ad=1.3p pd=5.52u as=1.3p ps=5.52u w=5u l=0.7u
X290 PAD_N a_86964_188004# VSS ppolyf_u r_width=2u r_length=2u
X291 VSS a_1852_148519# ESD_RAIL VSS nfet_06v0 ad=23.584p pd=0.10808m as=13.936p ps=54.12u w=53.6u l=0.7u
D19 PAD_N ESD_RAIL diode_pd2nw_06v0 pj=51.8u area=22.5p
X292 VSS ESD_RAIL VSS ppolyf_u_1k_6p0 r_width=1u r_length=9.98874m
X293 PAD_P a_46528_193864# VSS ppolyf_u r_width=2u r_length=3.05u
X294 ESD_RAIL a_1852_148519# VSS VSS nfet_06v0 ad=13.936p pd=54.12u as=13.936p ps=54.12u w=53.6u l=0.7u
X295 ESD_RAIL a_1852_148519# VSS VSS nfet_06v0 ad=13.936p pd=54.12u as=13.936p ps=54.12u w=53.6u l=0.7u
X296 a_4789_117064# a_3813_117064# ESD_RAIL ESD_RAIL pfet_06v0 ad=2.2p pd=10.88u as=1.3p ps=5.52u w=5u l=0.7u
X297 ESD_RAIL a_1852_148519# VSS VSS nfet_06v0 ad=13.936p pd=54.12u as=23.584p ps=0.10808m w=53.6u l=0.7u
X298 a_72012_187204# TERM_ENABLE TERM_VCM VSS nfet_06v0 ad=8.8p pd=40.88u as=8.8p ps=40.88u w=20u l=0.7u
X299 ESD_RAIL a_1852_148519# VSS VSS nfet_06v0 ad=13.936p pd=54.12u as=23.584p ps=0.10808m w=53.6u l=0.7u
X300 ESD_RAIL a_2245_90628# VSS VSS nfet_06v0 ad=13p pd=50.52u as=13p ps=50.52u w=50u l=0.7u
X301 VSS a_1852_148519# ESD_RAIL VSS nfet_06v0 ad=13.936p pd=54.12u as=13.936p ps=54.12u w=53.6u l=0.7u
X302 ESD_RAIL a_2245_90628# VSS VSS nfet_06v0 ad=13p pd=50.52u as=13p ps=50.52u w=50u l=0.7u
X303 ESD_RAIL a_1852_148519# VSS VSS nfet_06v0 ad=13.936p pd=54.12u as=13.936p ps=54.12u w=53.6u l=0.7u
X304 ESD_RAIL a_1852_148519# VSS VSS nfet_06v0 ad=13.936p pd=54.12u as=13.936p ps=54.12u w=53.6u l=0.7u
X305 PAD_N a_89100_188004# VSS ppolyf_u r_width=2u r_length=2u
X306 TERM_VCM TERM_ENABLE a_53920_193864# VSS nfet_06v0 ad=8.8p pd=40.88u as=8.8p ps=40.88u w=20u l=0.7u
X307 VSS a_1852_148519# ESD_RAIL VSS nfet_06v0 ad=13.936p pd=54.12u as=13.936p ps=54.12u w=53.6u l=0.7u
X308 a_75216_187204# TERM_ENABLE TERM_VCM VSS nfet_06v0 ad=8.8p pd=40.88u as=8.8p ps=40.88u w=20u l=0.7u
X309 TERM_VCM TERM_ENABLE a_51456_193864# VSS nfet_06v0 ad=8.8p pd=40.88u as=8.8p ps=40.88u w=20u l=0.7u
X310 PAD_N a_80556_188004# VSS ppolyf_u r_width=2u r_length=2u
X311 a_2245_90628# a_4789_117064# ESD_RAIL ESD_RAIL pfet_06v0 ad=1.3p pd=5.52u as=1.3p ps=5.52u w=5u l=0.7u
X312 VSS a_2245_90628# ESD_RAIL VSS nfet_06v0 ad=13p pd=50.52u as=13p ps=50.52u w=50u l=0.7u
X313 VSS a_1852_148519# ESD_RAIL VSS nfet_06v0 ad=13.936p pd=54.12u as=13.936p ps=54.12u w=53.6u l=0.7u
X314 ESD_RAIL a_2245_90628# VSS VSS nfet_06v0 ad=13p pd=50.52u as=13p ps=50.52u w=50u l=0.7u
X315 VSS a_1852_148519# ESD_RAIL VSS nfet_06v0 ad=13.936p pd=54.12u as=13.936p ps=54.12u w=53.6u l=0.7u
X316 a_1005_134065# a_13878_133785# ESD_RAIL ppolyf_u r_width=0.8u r_length=63.855u
X317 PAD_N a_75216_187204# VSS ppolyf_u r_width=2u r_length=3.05u
X318 ESD_RAIL a_1852_148519# VSS VSS nfet_06v0 ad=13.936p pd=54.12u as=13.936p ps=54.12u w=53.6u l=0.7u
X319 ESD_RAIL a_1852_148519# VSS VSS nfet_06v0 ad=13.936p pd=54.12u as=13.936p ps=54.12u w=53.6u l=0.7u
X320 PAD_P a_44064_193969# VSS ppolyf_u r_width=2u r_length=2u
X321 ESD_RAIL a_1852_148519# VSS VSS nfet_06v0 ad=13.936p pd=54.12u as=13.936p ps=54.12u w=53.6u l=0.7u
X322 VSS a_2245_90628# ESD_RAIL VSS nfet_06v0 ad=13p pd=50.52u as=13p ps=50.52u w=50u l=0.7u
X323 PAD_N a_66648_193864# VSS ppolyf_u r_width=2u r_length=3.05u
X324 VSS a_2245_90628# ESD_RAIL VSS nfet_06v0 ad=13p pd=50.52u as=13p ps=50.52u w=50u l=0.7u
X325 ESD_RAIL a_4789_117064# a_2245_90628# ESD_RAIL pfet_06v0 ad=1.3p pd=5.52u as=1.3p ps=5.52u w=5u l=0.7u
X326 ESD_RAIL a_1852_148519# VSS VSS nfet_06v0 ad=13.936p pd=54.12u as=13.936p ps=54.12u w=53.6u l=0.7u
X327 TERM_VCM TERM_TRIM0 a_44064_193969# VSS nfet_06v0 ad=5.28p pd=24.88u as=5.28p ps=24.88u w=12u l=0.7u
X328 VSS a_2245_90628# ESD_RAIL VSS nfet_06v0 ad=13p pd=50.52u as=13p ps=50.52u w=50u l=0.7u
X329 ESD_RAIL a_1852_148519# cap_mim_2f0_m4m5_noshield c_width=90u c_length=90u
D20 VSS ESD_RAIL diode_nd2ps_06v0 pj=82u area=40p
X330 ESD_RAIL a_1852_148519# VSS VSS nfet_06v0 ad=13.936p pd=54.12u as=13.936p ps=54.12u w=53.6u l=0.7u
X331 ESD_RAIL a_3813_117064# a_4789_117064# ESD_RAIL pfet_06v0 ad=1.3p pd=5.52u as=1.3p ps=5.52u w=5u l=0.7u
X332 VSS a_1852_148519# ESD_RAIL VSS nfet_06v0 ad=13.936p pd=54.12u as=13.936p ps=54.12u w=53.6u l=0.7u
X333 VSS a_1852_148519# ESD_RAIL VSS nfet_06v0 ad=13.936p pd=54.12u as=13.936p ps=54.12u w=53.6u l=0.7u
X334 VSS a_1852_148519# ESD_RAIL VSS nfet_06v0 ad=13.936p pd=54.12u as=13.936p ps=54.12u w=53.6u l=0.7u
X335 ESD_RAIL a_1852_148519# VSS VSS nfet_06v0 ad=13.936p pd=54.12u as=13.936p ps=54.12u w=53.6u l=0.7u
X336 a_2245_90628# a_4789_117064# ESD_RAIL ESD_RAIL pfet_06v0 ad=1.3p pd=5.52u as=1.3p ps=5.52u w=5u l=0.7u
X337 TERM_VCM TERM_ENABLE a_52688_193864# VSS nfet_06v0 ad=8.8p pd=40.88u as=8.8p ps=40.88u w=20u l=0.7u
X338 ESD_RAIL a_1852_148519# VSS VSS nfet_06v0 ad=13.936p pd=54.12u as=13.936p ps=54.12u w=53.6u l=0.7u
X339 VSS a_2245_90628# ESD_RAIL VSS nfet_06v0 ad=13p pd=50.52u as=13p ps=50.52u w=50u l=0.7u
X340 PAD_P a_36672_193969# VSS ppolyf_u r_width=2u r_length=2u
X341 VSS a_1852_148519# ESD_RAIL VSS nfet_06v0 ad=13.936p pd=54.12u as=13.936p ps=54.12u w=53.6u l=0.7u
X342 TERM_VCM TERM_ENABLE a_50224_193864# VSS nfet_06v0 ad=8.8p pd=40.88u as=8.8p ps=40.88u w=20u l=0.7u
X343 VSS a_1852_148519# ESD_RAIL VSS nfet_06v0 ad=13.936p pd=54.12u as=13.936p ps=54.12u w=53.6u l=0.7u
X344 VSS a_1852_148519# ESD_RAIL VSS nfet_06v0 ad=13.936p pd=54.12u as=13.936p ps=54.12u w=53.6u l=0.7u
X345 VSS a_1852_148519# ESD_RAIL VSS nfet_06v0 ad=13.936p pd=54.12u as=13.936p ps=54.12u w=53.6u l=0.7u
X346 a_3813_117064# a_1005_131545# ESD_RAIL ESD_RAIL pfet_06v0 ad=1.3p pd=5.52u as=2.2p ps=10.88u w=5u l=0.7u
X347 ESD_RAIL a_1852_148519# VSS VSS nfet_06v0 ad=13.936p pd=54.12u as=13.936p ps=54.12u w=53.6u l=0.7u
X348 ESD_RAIL a_2245_90628# VSS VSS nfet_06v0 ad=22p pd=0.10088m as=13p ps=50.52u w=50u l=0.7u
X349 ESD_RAIL a_1852_148519# VSS VSS nfet_06v0 ad=13.936p pd=54.12u as=13.936p ps=54.12u w=53.6u l=0.7u
X350 ESD_RAIL a_1852_148519# VSS VSS nfet_06v0 ad=13.936p pd=54.12u as=23.584p ps=0.10808m w=53.6u l=0.7u
X351 PAD_P a_56384_193864# VSS ppolyf_u r_width=2u r_length=3.05u
X352 ESD_RAIL a_2245_90628# VSS VSS nfet_06v0 ad=13p pd=50.52u as=13p ps=50.52u w=50u l=0.7u
X353 ESD_RAIL a_2245_90628# VSS VSS nfet_06v0 ad=13p pd=50.52u as=13p ps=50.52u w=50u l=0.7u
X354 VSS a_1852_148519# ESD_RAIL VSS nfet_06v0 ad=13.936p pd=54.12u as=13.936p ps=54.12u w=53.6u l=0.7u
X355 VSS a_1852_148519# ESD_RAIL VSS nfet_06v0 ad=23.584p pd=0.10808m as=13.936p ps=54.12u w=53.6u l=0.7u
X356 a_4789_117064# a_3813_117064# ESD_RAIL ESD_RAIL pfet_06v0 ad=1.3p pd=5.52u as=1.3p ps=5.52u w=5u l=0.7u
X357 ESD_RAIL a_1852_148519# VSS VSS nfet_06v0 ad=13.936p pd=54.12u as=13.936p ps=54.12u w=53.6u l=0.7u
X358 TERM_VCM TERM_TRIM1 a_42832_193969# VSS nfet_06v0 ad=5.28p pd=24.88u as=5.28p ps=24.88u w=12u l=0.7u
X359 VSS a_1852_148519# ESD_RAIL VSS nfet_06v0 ad=13.936p pd=54.12u as=13.936p ps=54.12u w=53.6u l=0.7u
X360 VSS a_1852_148519# ESD_RAIL VSS nfet_06v0 ad=13.936p pd=54.12u as=13.936p ps=54.12u w=53.6u l=0.7u
X361 ESD_RAIL a_1852_148519# VSS VSS nfet_06v0 ad=13.936p pd=54.12u as=13.936p ps=54.12u w=53.6u l=0.7u
X362 ESD_RAIL a_1852_148519# VSS VSS nfet_06v0 ad=13.936p pd=54.12u as=13.936p ps=54.12u w=53.6u l=0.7u
X363 PAD_P a_48992_193864# VSS ppolyf_u r_width=2u r_length=3.05u
X364 ESD_RAIL a_1852_148519# VSS VSS nfet_06v0 ad=13.936p pd=54.12u as=13.936p ps=54.12u w=53.6u l=0.7u
X365 ESD_RAIL a_1852_148519# VSS VSS nfet_06v0 ad=13.936p pd=54.12u as=13.936p ps=54.12u w=53.6u l=0.7u
X366 VSS a_2245_90628# ESD_RAIL VSS nfet_06v0 ad=13p pd=50.52u as=22p ps=0.10088m w=50u l=0.7u
X367 a_79488_188004# TERM_TRIM2 TERM_VCM VSS nfet_06v0 ad=5.28p pd=24.88u as=5.28p ps=24.88u w=12u l=0.7u
X368 VSS a_2245_90628# ESD_RAIL VSS nfet_06v0 ad=13p pd=50.52u as=13p ps=50.52u w=50u l=0.7u
X369 PAD_N a_82692_188004# VSS ppolyf_u r_width=2u r_length=2u
D21 PAD_P ESD_RAIL diode_pd2nw_06v0 pj=51.8u area=22.5p
X370 ESD_RAIL a_1852_148519# VSS VSS nfet_06v0 ad=13.936p pd=54.12u as=13.936p ps=54.12u w=53.6u l=0.7u
X371 TERM_VCM TERM_ENABLE a_48992_193864# VSS nfet_06v0 ad=8.8p pd=40.88u as=8.8p ps=40.88u w=20u l=0.7u
X372 VSS a_2245_90628# ESD_RAIL VSS nfet_06v0 ad=13p pd=50.52u as=13p ps=50.52u w=50u l=0.7u
X373 VSS a_2245_90628# ESD_RAIL VSS nfet_06v0 ad=13p pd=50.52u as=13p ps=50.52u w=50u l=0.7u
X374 VSS a_1852_148519# ESD_RAIL VSS nfet_06v0 ad=13.936p pd=54.12u as=13.936p ps=54.12u w=53.6u l=0.7u
X375 a_1852_148519# VSS VSS ppolyf_u_1k_6p0 r_width=1u r_length=6u
D22 PAD_P ESD_RAIL diode_pd2nw_06v0 pj=51.8u area=22.5p
X376 VSS a_1852_148519# ESD_RAIL VSS nfet_06v0 ad=13.936p pd=54.12u as=13.936p ps=54.12u w=53.6u l=0.7u
X377 ESD_RAIL a_1852_148519# VSS VSS nfet_06v0 ad=13.936p pd=54.12u as=13.936p ps=54.12u w=53.6u l=0.7u
X378 VSS a_1852_148519# ESD_RAIL VSS nfet_06v0 ad=13.936p pd=54.12u as=13.936p ps=54.12u w=53.6u l=0.7u
X379 VSS a_1852_148519# ESD_RAIL VSS nfet_06v0 ad=23.584p pd=0.10808m as=13.936p ps=54.12u w=53.6u l=0.7u
X380 VSS a_2245_90628# ESD_RAIL VSS nfet_06v0 ad=13p pd=50.52u as=13p ps=50.52u w=50u l=0.7u
X381 VSS a_1852_148519# ESD_RAIL VSS nfet_06v0 ad=13.936p pd=54.12u as=13.936p ps=54.12u w=53.6u l=0.7u
D23 VSS PAD_P diode_nd2ps_06v0 pj=51.8u area=22.5p
X382 ESD_RAIL a_1852_148519# VSS VSS nfet_06v0 ad=13.936p pd=54.12u as=23.584p ps=0.10808m w=53.6u l=0.7u
X383 ESD_RAIL a_2245_90628# VSS VSS nfet_06v0 ad=13p pd=50.52u as=13p ps=50.52u w=50u l=0.7u
X384 ESD_RAIL a_2245_90628# VSS VSS nfet_06v0 ad=13p pd=50.52u as=13p ps=50.52u w=50u l=0.7u
X385 VSS a_1852_148519# ESD_RAIL VSS nfet_06v0 ad=13.936p pd=54.12u as=13.936p ps=54.12u w=53.6u l=0.7u
X386 PAD_N a_76284_188004# VSS ppolyf_u r_width=2u r_length=2u
X387 ESD_RAIL a_1852_148519# VSS VSS nfet_06v0 ad=13.936p pd=54.12u as=13.936p ps=54.12u w=53.6u l=0.7u
X388 VSS a_3813_117064# a_4789_117064# VSS nfet_06v0 ad=1.3p pd=5.52u as=1.3p ps=5.52u w=5u l=0.7u
X389 ESD_RAIL a_1852_148519# VSS VSS nfet_06v0 ad=13.936p pd=54.12u as=13.936p ps=54.12u w=53.6u l=0.7u
X390 PAD_N a_72012_187204# VSS ppolyf_u r_width=2u r_length=3.05u
X391 VSS a_1852_148519# ESD_RAIL VSS nfet_06v0 ad=13.936p pd=54.12u as=13.936p ps=54.12u w=53.6u l=0.7u
X392 PAD_P a_40368_193969# VSS ppolyf_u r_width=2u r_length=2u
X393 a_89100_188004# TERM_TRIM3 TERM_VCM VSS nfet_06v0 ad=5.28p pd=24.88u as=5.28p ps=24.88u w=12u l=0.7u
X394 VSS a_2245_90628# ESD_RAIL VSS nfet_06v0 ad=13p pd=50.52u as=13p ps=50.52u w=50u l=0.7u
X395 PAD_P a_39136_193969# VSS ppolyf_u r_width=2u r_length=2u
X396 a_86964_188004# TERM_TRIM3 TERM_VCM VSS nfet_06v0 ad=5.28p pd=24.88u as=5.28p ps=24.88u w=12u l=0.7u
X397 ESD_RAIL a_1852_148519# VSS VSS nfet_06v0 ad=13.936p pd=54.12u as=23.584p ps=0.10808m w=53.6u l=0.7u
X398 ESD_RAIL a_1852_148519# VSS VSS nfet_06v0 ad=13.936p pd=54.12u as=13.936p ps=54.12u w=53.6u l=0.7u
X399 VSS a_4789_117064# a_2245_90628# VSS nfet_06v0 ad=1.3p pd=5.52u as=1.3p ps=5.52u w=5u l=0.7u
X400 VSS a_1852_148519# ESD_RAIL VSS nfet_06v0 ad=13.936p pd=54.12u as=13.936p ps=54.12u w=53.6u l=0.7u
X401 VSS a_4789_117064# a_2245_90628# VSS nfet_06v0 ad=1.3p pd=5.52u as=1.3p ps=5.52u w=5u l=0.7u
X402 VSS a_1852_148519# ESD_RAIL VSS nfet_06v0 ad=13.936p pd=54.12u as=13.936p ps=54.12u w=53.6u l=0.7u
X403 VSS a_1852_148519# ESD_RAIL VSS nfet_06v0 ad=13.936p pd=54.12u as=13.936p ps=54.12u w=53.6u l=0.7u
X404 ESD_RAIL a_4789_117064# a_2245_90628# ESD_RAIL pfet_06v0 ad=1.3p pd=5.52u as=1.3p ps=5.52u w=5u l=0.7u
X405 ESD_RAIL a_1852_148519# VSS VSS nfet_06v0 ad=13.936p pd=54.12u as=13.936p ps=54.12u w=53.6u l=0.7u
X406 VSS a_1852_148519# ESD_RAIL VSS nfet_06v0 ad=23.584p pd=0.10808m as=13.936p ps=54.12u w=53.6u l=0.7u
X407 PAD_P a_42832_193969# VSS ppolyf_u r_width=2u r_length=2u
X408 a_1005_131545# a_13878_131545# ESD_RAIL ppolyf_u r_width=0.8u r_length=63.855u
X409 VSS a_2245_90628# ESD_RAIL VSS nfet_06v0 ad=13p pd=50.52u as=13p ps=50.52u w=50u l=0.7u
X410 VSS a_2245_90628# ESD_RAIL VSS nfet_06v0 ad=13p pd=50.52u as=13p ps=50.52u w=50u l=0.7u
X411 ESD_RAIL a_1852_148519# VSS VSS nfet_06v0 ad=13.936p pd=54.12u as=13.936p ps=54.12u w=53.6u l=0.7u
X412 VSS a_1852_148519# ESD_RAIL VSS nfet_06v0 ad=13.936p pd=54.12u as=13.936p ps=54.12u w=53.6u l=0.7u
X413 VSS a_1852_148519# ESD_RAIL VSS nfet_06v0 ad=13.936p pd=54.12u as=13.936p ps=54.12u w=53.6u l=0.7u
X414 PAD_N a_78420_188004# VSS ppolyf_u r_width=2u r_length=2u
X415 PAD_P a_32976_193969# VSS ppolyf_u r_width=2u r_length=2u
X416 ESD_RAIL a_1852_148519# VSS VSS nfet_06v0 ad=13.936p pd=54.12u as=23.584p ps=0.10808m w=53.6u l=0.7u
X417 ESD_RAIL a_2245_90628# VSS VSS nfet_06v0 ad=13p pd=50.52u as=13p ps=50.52u w=50u l=0.7u
X418 a_4789_117064# a_3813_117064# VSS VSS nfet_06v0 ad=1.3p pd=5.52u as=1.3p ps=5.52u w=5u l=0.7u
X419 ESD_RAIL a_1852_148519# VSS VSS nfet_06v0 ad=13.936p pd=54.12u as=13.936p ps=54.12u w=53.6u l=0.7u
X420 ESD_RAIL a_1852_148519# VSS VSS nfet_06v0 ad=13.936p pd=54.12u as=23.584p ps=0.10808m w=53.6u l=0.7u
X421 VSS a_1852_148519# ESD_RAIL VSS nfet_06v0 ad=13.936p pd=54.12u as=13.936p ps=54.12u w=53.6u l=0.7u
D24 PAD_P ESD_RAIL diode_pd2nw_06v0 pj=51.8u area=22.5p
X422 PAD_P a_52688_193864# VSS ppolyf_u r_width=2u r_length=3.05u
X423 VSS a_1852_148519# ESD_RAIL VSS nfet_06v0 ad=13.936p pd=54.12u as=13.936p ps=54.12u w=53.6u l=0.7u
X424 a_2245_90628# a_4789_117064# ESD_RAIL ESD_RAIL pfet_06v0 ad=1.3p pd=5.52u as=1.3p ps=5.52u w=5u l=0.7u
X425 VSS a_1852_148519# ESD_RAIL VSS nfet_06v0 ad=13.936p pd=54.12u as=13.936p ps=54.12u w=53.6u l=0.7u
X426 ESD_RAIL a_1852_148519# VSS VSS nfet_06v0 ad=13.936p pd=54.12u as=13.936p ps=54.12u w=53.6u l=0.7u
X427 ESD_RAIL a_1852_148519# VSS VSS nfet_06v0 ad=13.936p pd=54.12u as=13.936p ps=54.12u w=53.6u l=0.7u
X428 a_88032_188004# TERM_TRIM3 TERM_VCM VSS nfet_06v0 ad=5.28p pd=24.88u as=5.28p ps=24.88u w=12u l=0.7u
X429 VSS a_1852_148519# ESD_RAIL VSS nfet_06v0 ad=13.936p pd=54.12u as=13.936p ps=54.12u w=53.6u l=0.7u
X430 a_85896_188004# TERM_TRIM3 TERM_VCM VSS nfet_06v0 ad=5.28p pd=24.88u as=5.28p ps=24.88u w=12u l=0.7u
X431 a_1005_132385# a_13878_132665# ESD_RAIL ppolyf_u r_width=0.8u r_length=63.855u
X432 ESD_RAIL a_2245_90628# VSS VSS nfet_06v0 ad=13p pd=50.52u as=13p ps=50.52u w=50u l=0.7u
X433 ESD_RAIL a_1852_148519# VSS VSS nfet_06v0 ad=13.936p pd=54.12u as=23.584p ps=0.10808m w=53.6u l=0.7u
X434 ESD_RAIL a_1852_148519# VSS VSS nfet_06v0 ad=13.936p pd=54.12u as=13.936p ps=54.12u w=53.6u l=0.7u
D25 VSS PAD_N diode_nd2ps_06v0 pj=51.8u area=22.5p
X435 VSS a_2245_90628# ESD_RAIL VSS nfet_06v0 ad=13p pd=50.52u as=13p ps=50.52u w=50u l=0.7u
X436 VSS a_1852_148519# ESD_RAIL VSS nfet_06v0 ad=23.584p pd=0.10808m as=13.936p ps=54.12u w=53.6u l=0.7u
X437 VSS a_2245_90628# ESD_RAIL VSS nfet_06v0 ad=13p pd=50.52u as=13p ps=50.52u w=50u l=0.7u
X438 PAD_N a_84828_188004# VSS ppolyf_u r_width=2u r_length=2u
X439 ESD_RAIL a_1852_148519# VSS VSS nfet_06v0 ad=13.936p pd=54.12u as=13.936p ps=54.12u w=53.6u l=0.7u
X440 VSS a_1852_148519# ESD_RAIL VSS nfet_06v0 ad=13.936p pd=54.12u as=13.936p ps=54.12u w=53.6u l=0.7u
X441 ESD_RAIL a_1852_148519# VSS VSS nfet_06v0 ad=13.936p pd=54.12u as=23.584p ps=0.10808m w=53.6u l=0.7u
X442 RX_N VDD VDD VDD pfet_06v0 ad=1.76p pd=8.88u as=1.76p ps=8.88u w=4u l=0.55u
X443 VSS a_1852_148519# ESD_RAIL VSS nfet_06v0 ad=13.936p pd=54.12u as=13.936p ps=54.12u w=53.6u l=0.7u
X444 ESD_RAIL a_4789_117064# a_2245_90628# ESD_RAIL pfet_06v0 ad=2.2p pd=10.88u as=1.3p ps=5.52u w=5u l=0.7u
X445 ESD_RAIL a_1852_148519# VSS VSS nfet_06v0 ad=13.936p pd=54.12u as=13.936p ps=54.12u w=53.6u l=0.7u
X446 VSS a_1852_148519# ESD_RAIL VSS nfet_06v0 ad=13.936p pd=54.12u as=13.936p ps=54.12u w=53.6u l=0.7u
X447 VSS a_1852_148519# ESD_RAIL VSS nfet_06v0 ad=13.936p pd=54.12u as=13.936p ps=54.12u w=53.6u l=0.7u
X448 VSS a_2245_90628# ESD_RAIL VSS nfet_06v0 ad=13p pd=50.52u as=13p ps=50.52u w=50u l=0.7u
X449 a_1005_133505# a_13878_133785# ESD_RAIL ppolyf_u r_width=0.8u r_length=63.855u
X450 VSS a_2245_90628# ESD_RAIL VSS nfet_06v0 ad=13p pd=50.52u as=13p ps=50.52u w=50u l=0.7u
X451 ESD_RAIL a_2245_90628# VSS VSS nfet_06v0 ad=13p pd=50.52u as=13p ps=50.52u w=50u l=0.7u
X452 ESD_RAIL a_1852_148519# VSS VSS nfet_06v0 ad=13.936p pd=54.12u as=13.936p ps=54.12u w=53.6u l=0.7u
X453 ESD_RAIL a_1852_148519# VSS VSS nfet_06v0 ad=13.936p pd=54.12u as=13.936p ps=54.12u w=53.6u l=0.7u
X454 ESD_RAIL a_1852_148519# VSS VSS nfet_06v0 ad=13.936p pd=54.12u as=13.936p ps=54.12u w=53.6u l=0.7u
X455 ESD_RAIL a_1852_148519# VSS VSS nfet_06v0 ad=13.936p pd=54.12u as=13.936p ps=54.12u w=53.6u l=0.7u
X456 VSS a_1852_148519# ESD_RAIL VSS nfet_06v0 ad=13.936p pd=54.12u as=13.936p ps=54.12u w=53.6u l=0.7u
X457 ESD_RAIL a_2245_90628# VSS VSS nfet_06v0 ad=13p pd=50.52u as=13p ps=50.52u w=50u l=0.7u
X458 a_84828_188004# TERM_TRIM3 TERM_VCM VSS nfet_06v0 ad=5.28p pd=24.88u as=5.28p ps=24.88u w=12u l=0.7u
X459 ESD_RAIL a_4789_117064# a_2245_90628# ESD_RAIL pfet_06v0 ad=1.3p pd=5.52u as=1.3p ps=5.52u w=5u l=0.7u
X460 ESD_RAIL a_1852_148519# VSS VSS nfet_06v0 ad=13.936p pd=54.12u as=23.584p ps=0.10808m w=53.6u l=0.7u
X461 ESD_RAIL a_1852_148519# VSS VSS nfet_06v0 ad=13.936p pd=54.12u as=13.936p ps=54.12u w=53.6u l=0.7u
X462 a_2245_90628# VSS VSS ppolyf_u_1k_6p0 r_width=1u r_length=99.24u
X463 TERM_VCM TERM_TRIM3 a_35440_193969# VSS nfet_06v0 ad=5.28p pd=24.88u as=5.28p ps=24.88u w=12u l=0.7u
X464 VSS a_1852_148519# ESD_RAIL VSS nfet_06v0 ad=13.936p pd=54.12u as=13.936p ps=54.12u w=53.6u l=0.7u
X465 VSS a_1852_148519# ESD_RAIL VSS nfet_06v0 ad=13.936p pd=54.12u as=13.936p ps=54.12u w=53.6u l=0.7u
X466 VSS a_1852_148519# ESD_RAIL VSS nfet_06v0 ad=13.936p pd=54.12u as=13.936p ps=54.12u w=53.6u l=0.7u
X467 VSS a_1852_148519# ESD_RAIL VSS nfet_06v0 ad=13.936p pd=54.12u as=13.936p ps=54.12u w=53.6u l=0.7u
D26 VSS PAD_N diode_nd2ps_06v0 pj=51.8u area=22.5p
X468 a_4789_117064# a_3813_117064# VSS VSS nfet_06v0 ad=1.3p pd=5.52u as=1.3p ps=5.52u w=5u l=0.7u
X469 TERM_VCM TERM_TRIM3 a_32976_193969# VSS nfet_06v0 ad=5.28p pd=24.88u as=5.28p ps=24.88u w=12u l=0.7u
D27 VSS ESD_RAIL diode_nd2ps_06v0 pj=82u area=40p
X470 VSS a_1852_148519# ESD_RAIL VSS nfet_06v0 ad=13.936p pd=54.12u as=13.936p ps=54.12u w=53.6u l=0.7u
X471 VSS a_1852_148519# ESD_RAIL VSS nfet_06v0 ad=13.936p pd=54.12u as=13.936p ps=54.12u w=53.6u l=0.7u
X472 PAD_N a_73080_187204# VSS ppolyf_u r_width=2u r_length=3.05u
X473 VSS a_2245_90628# ESD_RAIL VSS nfet_06v0 ad=13p pd=50.52u as=13p ps=50.52u w=50u l=0.7u
X474 VSS a_1852_148519# ESD_RAIL VSS nfet_06v0 ad=13.936p pd=54.12u as=13.936p ps=54.12u w=53.6u l=0.7u
X475 VSS a_2245_90628# ESD_RAIL VSS nfet_06v0 ad=13p pd=50.52u as=13p ps=50.52u w=50u l=0.7u
X476 VSS a_2245_90628# ESD_RAIL VSS nfet_06v0 ad=13p pd=50.52u as=13p ps=50.52u w=50u l=0.7u
X477 ESD_RAIL a_1852_148519# VSS VSS nfet_06v0 ad=13.936p pd=54.12u as=13.936p ps=54.12u w=53.6u l=0.7u
X478 ESD_RAIL a_1852_148519# VSS VSS nfet_06v0 ad=13.936p pd=54.12u as=13.936p ps=54.12u w=53.6u l=0.7u
X479 VSS a_2245_90628# ESD_RAIL VSS nfet_06v0 ad=13p pd=50.52u as=13p ps=50.52u w=50u l=0.7u
C0 a_13878_133785# ESD_RAIL 0.53942f
C1 a_80556_188004# a_77352_188004# 0.00715f
C2 a_46528_193864# a_47760_193864# 0.12196f
C3 PAD_P TERM_TRIM3 0.13708f
C4 a_90168_188004# PAD_N 0.04185f
C5 a_70944_187204# a_69876_187204# 0.07173f
C6 a_51456_193864# a_50224_193864# 0.07173f
C7 a_83760_188004# PAD_N 0.04185f
C8 RX_N VDD 2.31443f
C9 a_83760_188004# a_81624_188004# 0.1626f
C10 PAD_P TERM_ENABLE 0.13394f
C11 a_13878_133225# ESD_RAIL 0.53916f
C12 a_75216_187204# a_74148_187204# 0.32283f
C13 TERM_VCM a_32976_193969# 1.33262f
C14 TERM_ENABLE a_45296_193864# 0.34603f
C15 VBIAS TERM_TRIM3 4.61876f
C16 PAD_N TERM_TRIM3 0.15391f
C17 a_68808_187204# PAD_N 0.02841f
C18 a_86964_188004# a_90168_188004# 0.08066f
C19 TERM_VCM a_51456_193864# 1.55911f
C20 TERM_TRIM0 TERM_TRIM2 0.13755f
C21 a_81624_188004# TERM_TRIM3 0
C22 a_26816_193969# TERM_TRIM3 0.21106f
C23 a_86964_188004# a_83760_188004# 0.02726f
C24 a_73080_187204# TERM_ENABLE 0.34631f
C25 a_42832_193969# a_41600_193969# 0.17182f
C26 VDD w_53184_209128# 5.45334f
C27 TERM_VCM a_37904_193969# 1.98432f
C28 a_85896_188004# PAD_N 0.04185f
C29 a_79488_188004# a_77352_188004# 0.03597f
C30 TERM_TRIM1 VDD 0.20304f
C31 a_13878_132665# ESD_RAIL 0.53916f
C32 VBIAS TERM_ENABLE 0.26259f
C33 a_66648_193864# PAD_N 0.02841f
C34 TERM_VCM a_90168_188004# 1.1354f
C35 TERM_ENABLE PAD_N 0.13182f
C36 TERM_ENABLE a_52688_193864# 0.34621f
C37 a_29280_193969# a_34208_193969# 0.00449f
C38 a_86964_188004# TERM_TRIM3 0.21124f
C39 TERM_VCM a_83760_188004# 1.13637f
C40 TERM_VCM a_40368_193969# 1.5022f
C41 TERM_ENABLE a_56384_193864# 0.34621f
C42 a_1852_148519# ESD_RAIL 0.33756p
C43 PAD_P TERM_TRIM2 0.07741f
C44 TERM_TRIM1 a_41600_193969# 0.21106f
C45 TERM_TRIM2 a_39136_193969# 0.21124f
C46 RX_N w_53184_209128# 2.38528f
C47 TERM_TRIM1 a_42832_193969# 0.21124f
C48 a_75216_187204# a_77352_188004# 0.01596f
C49 a_13878_132105# ESD_RAIL 0.53942f
C50 a_44064_193969# a_41600_193969# 0.13387f
C51 TERM_ENABLE a_50224_193864# 0.34716f
C52 a_86964_188004# a_85896_188004# 0.85543f
C53 PAD_P a_46528_193864# 0.02841f
C54 a_42832_193969# a_44064_193969# 0.38185f
C55 TERM_VCM TERM_TRIM3 3.54683f
C56 a_46528_193864# a_45296_193864# 0.32283f
C57 a_89100_188004# a_88032_188004# 0.02179f
C58 PAD_P a_1852_148519# 0.25621f
C59 a_68808_187204# TERM_VCM 1.50642f
C60 a_29280_193969# a_31744_193969# 0.16889f
C61 TERM_TRIM0 RX_P 0
C62 a_36672_193969# a_34208_193969# 0.21287f
C63 TERM_VCM a_85896_188004# 1.33262f
C64 PAD_P a_53920_193864# 0.02841f
C65 TERM_TRIM1 w_53184_209128# 0.21318f
C66 VBIAS TERM_TRIM2 0.26335f
C67 TERM_TRIM2 PAD_N 0.07672f
C68 a_66648_193864# TERM_VCM 1.40781f
C69 a_1005_131545# ESD_RAIL 97.1325f
C70 TERM_VCM TERM_ENABLE 8.4531f
C71 TERM_TRIM1 a_44064_193969# 0
C72 TERM_TRIM2 a_81624_188004# 0.21125f
C73 ESD_RAIL m2_2279_124800# 5.47988f
C74 PAD_N a_82692_188004# 0.04185f
C75 PAD_N a_78420_188004# 0.0455f
C76 a_76284_188004# TERM_ENABLE 0
C77 a_1852_148519# PAD_N 0.0757f
C78 a_29280_193969# a_28048_193969# 1.01318f
C79 ESD_RAIL a_3813_117064# 5.25092f
C80 a_82692_188004# a_81624_188004# 0.64047f
C81 PAD_P RX_P 14.8446f
C82 TERM_TRIM1 a_77352_188004# 0.21124f
C83 a_36672_193969# a_31744_193969# 0.00355f
C84 a_1005_131545# a_1005_131825# 0.03725f
C85 a_29280_193969# a_30512_193969# 0.02179f
C86 a_69876_187204# PAD_N 0.02841f
C87 a_88032_188004# a_84828_188004# 0.31618f
C88 a_52688_193864# a_53920_193864# 0.0582f
C89 a_32976_193969# TERM_TRIM3 0.21124f
C90 a_1005_131545# a_1005_132385# 0
C91 a_1005_131825# m2_2279_124800# 0
C92 ESD_RAIL a_2245_90628# 0.24349p
C93 PAD_P a_29280_193969# 0.04185f
C94 a_80556_188004# PAD_N 0.04185f
C95 a_67740_187204# PAD_N 0.02841f
C96 a_37904_193969# a_40368_193969# 0.06432f
C97 a_1005_131545# a_1005_132945# 0
C98 a_1005_132385# m2_2279_124800# 0
C99 a_86964_188004# a_82692_188004# 0.00355f
C100 VDD TERM_TRIM0 0.20278f
C101 a_80556_188004# a_81624_188004# 0.18702f
C102 a_47760_193864# a_48992_193864# 0.0804f
C103 a_89100_188004# PAD_N 0.04185f
C104 a_1005_132945# m2_2279_124800# 0
C105 a_72012_187204# a_70944_187204# 0.16284f
C106 VBIAS RX_P 0.079f
C107 TERM_TRIM2 TERM_VCM 1.84724f
C108 TERM_TRIM0 a_75216_187204# 0
C109 a_37904_193969# TERM_TRIM3 0
C110 a_1005_133505# m2_2279_124800# 0
C111 a_36672_193969# a_35440_193969# 0.69466f
C112 a_91236_188004# a_88032_188004# 0
C113 TERM_VCM a_46528_193864# 1.7715f
C114 TERM_VCM a_82692_188004# 1.23609f
C115 a_1005_134065# m2_2279_124800# 0
C116 a_90168_188004# TERM_TRIM3 0.21124f
C117 TERM_VCM a_78420_188004# 1.14109f
C118 RX_N TERM_TRIM0 0
C119 TERM_ENABLE a_51456_193864# 0.34621f
C120 PAD_P a_36672_193969# 0.04185f
C121 a_83760_188004# TERM_TRIM3 0.21124f
C122 VDD PAD_P 0.39442f
C123 a_39136_193969# a_36672_193969# 0.10767f
C124 a_76284_188004# a_78420_188004# 0.13387f
C125 a_89100_188004# a_86964_188004# 0.16889f
C126 a_90168_188004# a_85896_188004# 0.00866f
C127 a_69876_187204# TERM_VCM 1.55911f
C128 TERM_VCM a_53920_193864# 1.45374f
C129 a_26816_193969# a_29280_193969# 0.129f
C130 TERM_VCM a_80556_188004# 1.14221f
C131 a_67740_187204# TERM_VCM 1.45374f
C132 a_85896_188004# a_83760_188004# 0.26567f
C133 PAD_N a_79488_188004# 0.04185f
C134 a_13878_133785# a_13878_134345# 0.0346f
C135 TERM_TRIM0 w_53184_209128# 0.29377f
C136 a_89100_188004# TERM_VCM 1.78464f
C137 a_79488_188004# a_81624_188004# 0.06432f
C138 PAD_N a_84828_188004# 0.04185f
C139 TERM_TRIM1 TERM_TRIM0 31.6187f
C140 PAD_P a_41600_193969# 0.0455f
C141 PAD_P a_42832_193969# 0.04185f
C142 TERM_TRIM0 a_44064_193969# 0.21106f
C143 a_41600_193969# a_39136_193969# 0
C144 a_45296_193864# a_41600_193969# 0
C145 RX_P TERM_VCM 3.10869f
C146 a_42832_193969# a_39136_193969# 0.00715f
C147 VDD VBIAS 4.64217f
C148 a_85896_188004# TERM_TRIM3 0.21124f
C149 a_84828_188004# a_81624_188004# 0.01397f
C150 a_42832_193969# a_45296_193864# 0.01596f
C151 a_73080_187204# a_75216_187204# 0.01025f
C152 VDD PAD_N 0.39442f
C153 ESD_RAIL w_53184_209128# 0.08713f
C154 a_1005_131545# a_4789_117064# 0.02926f
C155 TERM_ENABLE TERM_TRIM3 0.13619f
C156 a_73080_187204# a_74148_187204# 0.12196f
C157 a_68808_187204# TERM_ENABLE 0.34621f
C158 a_75216_187204# PAD_N 0.02856f
C159 TERM_VCM a_29280_193969# 1.78464f
C160 a_91236_188004# PAD_N 0.04035f
C161 a_34208_193969# a_31744_193969# 0.1215f
C162 PAD_P w_53184_209128# 0.48419f
C163 PAD_N a_74148_187204# 0.02841f
C164 TERM_TRIM2 a_37904_193969# 0.21125f
C165 a_4789_117064# a_3813_117064# 3.03168f
C166 a_86964_188004# a_84828_188004# 0.1215f
C167 TERM_TRIM1 PAD_P 0.07741f
C168 PAD_P a_48992_193864# 0.02841f
C169 RX_N VBIAS 0.079f
C170 PAD_P a_44064_193969# 0.04185f
C171 RX_N PAD_N 14.8446f
C172 a_66648_193864# TERM_ENABLE 0.34621f
C173 a_44064_193969# a_45296_193864# 0.2179f
C174 TERM_VCM a_79488_188004# 1.5022f
C175 PAD_P a_55152_193864# 0.02841f
C176 a_13878_133225# a_13878_133785# 0.0346f
C177 a_4789_117064# a_2245_90628# 11.6307f
C178 TERM_TRIM2 a_40368_193969# 0.21124f
C179 TERM_VCM a_84828_188004# 2.15129f
C180 a_76284_188004# a_79488_188004# 0
C181 a_91236_188004# a_86964_188004# 0.0102f
C182 a_83760_188004# a_82692_188004# 0.69466f
C183 TERM_VCM a_36672_193969# 1.23609f
C184 a_13878_132105# a_13878_131545# 0.0346f
C185 VBIAS w_53184_209128# 2.3971f
C186 VDD TERM_VCM 0.68472f
C187 a_72012_187204# a_73080_187204# 0.0804f
C188 TERM_TRIM1 VBIAS 0.26292f
C189 PAD_N w_53184_209128# 8.24224f
C190 a_35440_193969# a_34208_193969# 0.10088f
C191 TERM_TRIM2 TERM_TRIM3 36.6983f
C192 TERM_TRIM1 PAD_N 0.07529f
C193 a_34208_193969# a_30512_193969# 0.31618f
C194 a_75216_187204# TERM_VCM 1.41027f
C195 a_72012_187204# PAD_N 0.02841f
C196 a_82692_188004# TERM_TRIM3 0
C197 a_91236_188004# TERM_VCM 0.94575f
C198 PAD_P a_47760_193864# 0.02841f
C199 a_29280_193969# a_32976_193969# 0.0331f
C200 PAD_P a_34208_193969# 0.04185f
C201 TERM_VCM a_74148_187204# 1.7715f
C202 a_47760_193864# a_45296_193864# 0.01025f
C203 a_83760_188004# a_80556_188004# 0.01123f
C204 a_75216_187204# a_76284_188004# 0.2179f
C205 a_89100_188004# a_90168_188004# 1.01318f
C206 PAD_N a_77352_188004# 0.04185f
C207 TERM_VCM a_41600_193969# 1.14109f
C208 a_50224_193864# a_48992_193864# 0.16284f
C209 RX_N TERM_VCM 3.10869f
C210 TERM_VCM a_42832_193969# 1.34775f
C211 TERM_TRIM2 TERM_ENABLE 0.14082f
C212 a_55152_193864# a_56384_193864# 0.05357f
C213 a_85896_188004# a_82692_188004# 0.01848f
C214 a_31744_193969# a_28048_193969# 0.08066f
C215 a_76284_188004# a_74148_187204# 0.01248f
C216 a_70944_187204# a_73080_187204# 0
C217 a_35440_193969# a_31744_193969# 0.02726f
C218 a_68808_187204# a_69876_187204# 0.06277f
C219 TERM_ENABLE a_46528_193864# 0.34634f
C220 a_31744_193969# a_30512_193969# 0.1211f
C221 a_13878_132665# a_13878_133225# 0.0346f
C222 a_68808_187204# a_67740_187204# 0.0582f
C223 a_70944_187204# PAD_N 0.02841f
C224 a_89100_188004# TERM_TRIM3 0.21132f
C225 PAD_P a_31744_193969# 0.04185f
C226 a_36672_193969# a_32976_193969# 0.01848f
C227 TERM_VCM w_53184_209128# 0.72336f
C228 TERM_TRIM1 TERM_VCM 0.99638f
C229 TERM_VCM a_48992_193864# 1.42307f
C230 TERM_ENABLE a_53920_193864# 0.34621f
C231 a_69876_187204# TERM_ENABLE 0.34621f
C232 TERM_VCM a_44064_193969# 1.71924f
C233 a_67740_187204# a_66648_193864# 0.05543f
C234 a_72012_187204# TERM_VCM 1.42307f
C235 a_89100_188004# a_85896_188004# 0.0331f
C236 a_67740_187204# TERM_ENABLE 0.34621f
C237 TERM_TRIM1 a_76284_188004# 0
C238 TERM_TRIM0 PAD_P 0.07741f
C239 TERM_VCM a_55152_193864# 1.40781f
C240 a_30512_193969# a_28048_193969# 0
C241 TERM_TRIM0 a_45296_193864# 0
C242 a_29280_193969# TERM_TRIM3 0.21132f
C243 a_50224_193864# a_47760_193864# 0
C244 a_37904_193969# a_36672_193969# 0.64047f
C245 TERM_VCM a_77352_188004# 1.34775f
C246 a_35440_193969# a_30512_193969# 0
C247 PAD_P a_28048_193969# 0.04185f
C248 RX_P TERM_ENABLE 0
C249 a_83760_188004# a_84828_188004# 0.10088f
C250 PAD_P ESD_RAIL 49.4072f
C251 PAD_P a_35440_193969# 0.04185f
C252 a_76284_188004# a_77352_188004# 0.38185f
C253 TERM_TRIM2 a_82692_188004# 0.21106f
C254 a_39136_193969# a_35440_193969# 0.01123f
C255 ESD_RAIL a_1005_131825# 0.53823f
C256 PAD_P a_30512_193969# 0.04745f
C257 TERM_TRIM2 a_78420_188004# 0
C258 a_40368_193969# a_36672_193969# 0.00939f
C259 a_70944_187204# TERM_VCM 1.62038f
C260 a_26816_193969# a_31744_193969# 0.0102f
C261 a_13878_132105# a_13878_132665# 0.0346f
C262 ESD_RAIL a_1005_132385# 0.53823f
C263 TERM_TRIM0 VBIAS 0.26259f
C264 a_91236_188004# a_90168_188004# 1.06738f
C265 a_65416_193864# PAD_N 0.08723f
C266 TERM_VCM a_47760_193864# 1.48038f
C267 a_84828_188004# TERM_TRIM3 0.21127f
C268 TERM_TRIM0 PAD_N 0.07529f
C269 a_88032_188004# PAD_N 0.04745f
C270 TERM_VCM a_34208_193969# 2.15129f
C271 PAD_P a_39136_193969# 0.04185f
C272 PAD_P a_45296_193864# 0.02856f
C273 ESD_RAIL a_1005_132945# 0.53823f
C274 a_36672_193969# TERM_TRIM3 0
C275 VDD TERM_TRIM3 3.97522f
C276 TERM_TRIM2 a_80556_188004# 0.21124f
C277 ESD_RAIL a_1005_133505# 0.53842f
C278 a_85896_188004# a_84828_188004# 0.77264f
C279 ESD_RAIL PAD_N 44.6465f
C280 ESD_RAIL a_1005_134065# 0.57348f
C281 a_1005_131825# a_1005_132385# 0.0346f
C282 a_41600_193969# a_40368_193969# 0.02726f
C283 a_80556_188004# a_82692_188004# 0.10767f
C284 a_51456_193864# a_48992_193864# 0
C285 a_42832_193969# a_40368_193969# 0.03597f
C286 a_91236_188004# TERM_TRIM3 0.21106f
C287 a_80556_188004# a_78420_188004# 0
C288 a_26816_193969# a_28048_193969# 1.06738f
C289 PAD_P VBIAS 0.15544f
C290 a_86964_188004# a_88032_188004# 0.1211f
C291 PAD_P PAD_N 28.1675f
C292 TERM_VCM a_31744_193969# 1.13649f
C293 PAD_P a_52688_193864# 0.02841f
C294 a_1005_132385# a_1005_132945# 0.0346f
C295 VDD TERM_ENABLE 0.20956f
C296 a_26816_193969# a_30512_193969# 0
C297 PAD_P a_56384_193864# 0.08723f
C298 PAD_P a_26816_193969# 0.04035f
C299 a_75216_187204# TERM_ENABLE 0.34603f
C300 a_1005_132945# a_1005_133505# 0.0346f
C301 a_65416_193864# TERM_VCM 1.34664f
C302 TERM_TRIM0 TERM_VCM 0.57211f
C303 TERM_VCM a_88032_188004# 1.14097f
C304 TERM_ENABLE a_74148_187204# 0.34634f
C305 a_44064_193969# a_40368_193969# 0
C306 PAD_P a_50224_193864# 0.02841f
C307 a_32976_193969# a_34208_193969# 0.77264f
C308 a_73080_187204# PAD_N 0.02841f
C309 TERM_TRIM0 a_76284_188004# 0.21106f
C310 RX_N TERM_ENABLE 0
C311 a_1005_133505# a_1005_134065# 0.0346f
C312 w_53184_209128# TERM_TRIM3 0.21966f
C313 TERM_TRIM2 a_79488_188004# 0.21124f
C314 VBIAS PAD_N 0.15544f
C315 TERM_VCM a_28048_193969# 1.1354f
C316 TERM_TRIM1 TERM_TRIM3 0.13916f
C317 TERM_VCM a_35440_193969# 1.13637f
C318 a_82692_188004# a_79488_188004# 0.00939f
C319 PAD_N a_81624_188004# 0.04185f
C320 TERM_VCM a_30512_193969# 1.14097f
C321 a_4789_117064# ESD_RAIL 16.8853f
C322 a_78420_188004# a_79488_188004# 0.02726f
C323 a_37904_193969# a_34208_193969# 0.01397f
C324 TERM_TRIM2 a_36672_193969# 0.21106f
C325 PAD_P TERM_VCM 1.60174f
C326 a_82692_188004# a_84828_188004# 0.21287f
C327 VDD TERM_TRIM2 0.2054f
C328 TERM_VCM a_39136_193969# 1.14221f
C329 a_1005_131545# m2_2279_124800# 0.05457f
C330 a_32976_193969# a_31744_193969# 0.85543f
C331 TERM_VCM a_45296_193864# 1.41027f
C332 TERM_ENABLE w_53184_209128# 15.25f
C333 TERM_ENABLE a_48992_193864# 0.34673f
C334 TERM_TRIM1 TERM_ENABLE 0.15333f
C335 a_1005_131545# a_3813_117064# 2.44008f
C336 TERM_ENABLE a_44064_193969# 0
C337 a_86964_188004# PAD_N 0.04185f
C338 a_80556_188004# a_79488_188004# 0.55795f
C339 a_72012_187204# TERM_ENABLE 0.34673f
C340 TERM_ENABLE a_55152_193864# 0.34621f
C341 a_73080_187204# TERM_VCM 1.48038f
C342 a_75216_187204# a_78420_188004# 0
C343 TERM_TRIM2 a_41600_193969# 0
C344 a_1005_131545# a_2245_90628# 0.01301f
C345 a_34208_193969# TERM_TRIM3 0.21127f
C346 VBIAS TERM_VCM 0.33632f
C347 TERM_VCM PAD_N 1.60174f
C348 a_32976_193969# a_28048_193969# 0.00866f
C349 TERM_VCM a_52688_193864# 1.50642f
C350 a_89100_188004# a_84828_188004# 0.00449f
C351 a_35440_193969# a_32976_193969# 0.26567f
C352 TERM_VCM a_81624_188004# 1.98432f
C353 a_3813_117064# a_2245_90628# 0.00994f
C354 a_76284_188004# PAD_N 0.04185f
C355 TERM_VCM a_56384_193864# 1.34664f
C356 a_32976_193969# a_30512_193969# 0.13566f
C357 TERM_VCM a_26816_193969# 0.94575f
C358 a_70944_187204# TERM_ENABLE 0.34716f
C359 VDD RX_P 2.31443f
C360 TERM_ENABLE a_47760_193864# 0.34631f
C361 a_90168_188004# a_88032_188004# 0
C362 TERM_TRIM2 w_53184_209128# 0.20938f
C363 PAD_P a_32976_193969# 0.04185f
C364 TERM_TRIM1 TERM_TRIM2 33.4699f
C365 TERM_VCM a_50224_193864# 1.62038f
C366 a_91236_188004# a_89100_188004# 0.129f
C367 a_31744_193969# TERM_TRIM3 0.21124f
C368 a_37904_193969# a_35440_193969# 0.1626f
C369 a_88032_188004# a_83760_188004# 0
C370 a_86964_188004# TERM_VCM 1.13649f
C371 ESD_RAIL a_13878_131545# 0.56772f
C372 PAD_P a_51456_193864# 0.02841f
C373 TERM_TRIM1 a_78420_188004# 0.21106f
C374 a_46528_193864# a_44064_193969# 0.01248f
C375 PAD_P a_37904_193969# 0.04185f
C376 a_88032_188004# TERM_TRIM3 0.21124f
C377 TERM_TRIM0 TERM_TRIM3 0.13392f
C378 a_39136_193969# a_37904_193969# 0.18702f
C379 a_13878_134345# ESD_RAIL 0.5677f
C380 a_78420_188004# a_77352_188004# 0.17182f
C381 a_28048_193969# TERM_TRIM3 0.21124f
C382 a_72012_187204# a_69876_187204# 0
C383 a_35440_193969# TERM_TRIM3 0.21124f
C384 a_88032_188004# a_85896_188004# 0.13566f
C385 TERM_VCM a_76284_188004# 1.71924f
C386 PAD_P a_40368_193969# 0.04185f
C387 a_55152_193864# a_53920_193864# 0.05543f
C388 a_39136_193969# a_40368_193969# 0.55795f
C389 a_65416_193864# a_66648_193864# 0.05357f
C390 a_30512_193969# TERM_TRIM3 0.21124f
C391 a_65416_193864# TERM_ENABLE 0.34621f
C392 a_51456_193864# a_52688_193864# 0.06277f
C393 TERM_TRIM0 TERM_ENABLE 30.484f
C394 RX_P w_53184_209128# 2.38501f
C395 TERM_ENABLE VSS 38.4974f
C396 TERM_TRIM0 VSS 7.6695f
C397 TERM_TRIM1 VSS 11.4569f
C398 TERM_TRIM2 VSS 19.2319f
C399 TERM_VCM VSS 0.12235p
C400 TERM_TRIM3 VSS 45.8343f
C401 PAD_N VSS 0.35425p
C402 PAD_P VSS 0.36985p
C403 RX_N VSS 36.0222f
C404 VBIAS VSS 3.47277f
C405 RX_P VSS 36.0222f
C406 ESD_RAIL VSS 2978.62133f
C407 VDD VSS 25.6749f
C408 m2_2279_124800# VSS 7.46506f $ **FLOATING
C409 a_2245_90628# VSS 0.24972p
C410 a_4789_117064# VSS 8.91806f
C411 a_3813_117064# VSS 5.17875f
C412 a_1005_131545# VSS 98.15211f
C413 a_13878_131545# VSS 0.07835f
C414 a_1005_131825# VSS 0.07377f
C415 a_13878_132105# VSS 0.07394f
C416 a_1005_132385# VSS 0.07377f
C417 a_13878_132665# VSS 0.07394f
C418 a_1005_132945# VSS 0.07377f
C419 a_13878_133225# VSS 0.07394f
C420 a_1005_133505# VSS 0.07377f
C421 a_13878_133785# VSS 0.07394f
C422 a_1005_134065# VSS 0.07377f
C423 a_13878_134345# VSS 0.07838f
C424 a_1852_148519# VSS 0.41778p
C425 a_91236_188004# VSS 4.53629f
C426 a_90168_188004# VSS 3.43891f
C427 a_89100_188004# VSS 3.37039f
C428 a_88032_188004# VSS 4.71404f
C429 a_86964_188004# VSS 4.18037f
C430 a_85896_188004# VSS 3.10965f
C431 a_84828_188004# VSS 2.88432f
C432 a_83760_188004# VSS 3.96932f
C433 a_82692_188004# VSS 3.19002f
C434 a_81624_188004# VSS 3.0172f
C435 a_80556_188004# VSS 3.84876f
C436 a_79488_188004# VSS 3.25899f
C437 a_78420_188004# VSS 3.9821f
C438 a_77352_188004# VSS 3.36022f
C439 a_76284_188004# VSS 2.98519f
C440 a_75216_187204# VSS 3.95769f
C441 a_74148_187204# VSS 3.75737f
C442 a_73080_187204# VSS 3.90066f
C443 a_72012_187204# VSS 4.00403f
C444 a_70944_187204# VSS 3.71772f
C445 a_69876_187204# VSS 3.72171f
C446 a_68808_187204# VSS 3.69238f
C447 a_67740_187204# VSS 3.66017f
C448 a_66648_193864# VSS 3.66977f
C449 a_65416_193864# VSS 3.65691f
C450 a_56384_193864# VSS 3.65691f
C451 a_55152_193864# VSS 3.66977f
C452 a_53920_193864# VSS 3.66017f
C453 a_52688_193864# VSS 3.69238f
C454 a_51456_193864# VSS 3.72171f
C455 a_50224_193864# VSS 3.71772f
C456 a_48992_193864# VSS 4.00403f
C457 a_47760_193864# VSS 3.90066f
C458 a_46528_193864# VSS 3.75737f
C459 a_45296_193864# VSS 3.95769f
C460 a_44064_193969# VSS 2.98519f
C461 a_42832_193969# VSS 3.36022f
C462 a_41600_193969# VSS 3.9821f
C463 a_40368_193969# VSS 3.25899f
C464 a_39136_193969# VSS 3.84876f
C465 a_37904_193969# VSS 3.0172f
C466 a_36672_193969# VSS 3.19002f
C467 a_35440_193969# VSS 3.96932f
C468 a_34208_193969# VSS 2.88432f
C469 a_32976_193969# VSS 3.10965f
C470 a_31744_193969# VSS 4.18037f
C471 a_30512_193969# VSS 4.71404f
C472 a_29280_193969# VSS 3.37039f
C473 a_28048_193969# VSS 3.43891f
C474 a_26816_193969# VSS 4.53629f
C475 w_53184_209128# VSS 90.5221f
DWELL_ARRAY VSS ESD_RAIL diode_nw2ps_06v0 area=1138.9056p pj=941.44u
.ends
