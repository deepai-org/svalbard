.subckt tx_protected_pad PAD_P PAD_N VDD VSS TERM_VCM TERM_ENABLE DIFF_ENABLE DIV_ENABLE BYPASS_ENABLE RX_P RX_N HS_PBIAS HS_P HS_N FS_HIGH_P FS_HIGH_N FS_LOW_P FS_LOW_N PULLUP_P PULLUP_N PULLDOWN_P PULLDOWN_N ATB_ESD_RAIL
XPHYSICAL PAD_P PAD_N VDD VSS TERM_VCM TERM_ENABLE DIFF_ENABLE DIV_ENABLE BYPASS_ENABLE RX_P RX_N HS_PBIAS HS_P HS_N FS_HIGH_P FS_HIGH_N FS_LOW_P FS_LOW_N PULLUP_P PULLUP_N PULLDOWN_P PULLDOWN_N ESD_RAIL ATB_ESD_RAIL combined_flat
.ends tx_protected_pad
* NGSPICE file created from combined_flat.ext - technology: gf180mcuD

.subckt combined_flat PAD_P PAD_N VDD VSS TERM_VCM TERM_ENABLE DIFF_ENABLE DIV_ENABLE
+ BYPASS_ENABLE RX_P RX_N HS_PBIAS HS_P HS_N FS_HIGH_P FS_HIGH_N FS_LOW_P FS_LOW_N
+ PULLUP_P PULLUP_N PULLDOWN_P PULLDOWN_N ESD_RAIL ATB_ESD_RAIL
X0 VSS a_42245_90628# ESD_RAIL VSS nfet_06v0 ad=13p pd=50.52u as=13p ps=50.52u w=50u l=0.7u
X1 VSS a_41852_148519# ESD_RAIL VSS nfet_06v0 ad=13.936p pd=54.12u as=13.936p ps=54.12u w=53.6u l=0.7u
X2 ESD_RAIL a_41852_148519# VSS VSS nfet_06v0 ad=13.936p pd=54.12u as=13.936p ps=54.12u w=53.6u l=0.7u
X3 FS_N_OUT FS_N_GATE FS_N_WELL FS_N_WELL pfet_03v3 ad=6.16p pd=28.88u as=6.16p ps=28.88u w=14u l=0.28u
X4 a_42245_90628# a_44789_117064# VSS VSS nfet_06v0 ad=1.3p pd=5.52u as=1.3p ps=5.52u w=5u l=0.7u
X5 ESD_RAIL a_44789_117064# a_42245_90628# ESD_RAIL pfet_06v0 ad=1.3p pd=5.52u as=1.3p ps=5.52u w=5u l=0.7u
X6 VSS a_41852_148519# ESD_RAIL VSS nfet_06v0 ad=13.936p pd=54.12u as=13.936p ps=54.12u w=53.6u l=0.7u
X7 TERM_P_R TERM_GATE_P TERM_VCM VSS nfet_03v3 ad=8.8p pd=40.88u as=8.8p ps=40.88u w=20u l=0.28u
X8 ESD_RAIL a_42245_90628# VSS VSS nfet_06v0 ad=13p pd=50.52u as=13p ps=50.52u w=50u l=0.7u
X9 a_42245_90628# a_44789_117064# ESD_RAIL ESD_RAIL pfet_06v0 ad=1.3p pd=5.52u as=1.3p ps=5.52u w=5u l=0.7u
X10 ESD_RAIL a_41005_131545# a_43813_117064# ESD_RAIL pfet_06v0 ad=1.3p pd=5.52u as=1.3p ps=5.52u w=5u l=0.7u
X11 HS_N_5 HS_N PAD_N VSS nfet_06v0 ad=8.8p pd=40.88u as=8.8p ps=40.88u w=20u l=0.7u
X12 ESD_RAIL a_41852_148519# VSS VSS nfet_06v0 ad=13.936p pd=54.12u as=13.936p ps=54.12u w=53.6u l=0.7u
X13 TERM_GATE_P TERM_GATE_P_BLEED_0 VSS ppolyf_u_1k r_width=1u r_length=12.5u
X14 FS_P_GATE FS_HIGH_P FS_P_WELL FS_P_WELL pfet_03v3 ad=1.76p pd=8.88u as=1.76p ps=8.88u w=4u l=0.28u
X15 VSS a_41852_148519# ESD_RAIL VSS nfet_06v0 ad=13.936p pd=54.12u as=13.936p ps=54.12u w=53.6u l=0.7u
X16 ESD_RAIL ATB_ESD_RAIL VSS ppolyf_u_1k_6p0 r_width=1u r_length=0.47474m
X17 FS_P_CONTROL_S VDD VSS VSS nfet_03v3 ad=1.76p pd=8.88u as=1.76p ps=8.88u w=4u l=0.28u
X18 ESD_RAIL a_41852_148519# VSS VSS nfet_06v0 ad=13.936p pd=54.12u as=13.936p ps=54.12u w=53.6u l=0.7u
X19 ESD_RAIL a_42245_90628# VSS VSS nfet_06v0 ad=13p pd=50.52u as=13p ps=50.52u w=50u l=0.7u
X20 a_42245_90628# a_44789_117064# ESD_RAIL ESD_RAIL pfet_06v0 ad=1.3p pd=5.52u as=1.3p ps=5.52u w=5u l=0.7u
X21 ESD_RAIL a_41852_148519# VSS VSS nfet_06v0 ad=13.936p pd=54.12u as=13.936p ps=54.12u w=53.6u l=0.7u
X22 HS_P_4 HS_PBIAS VDD VDD pfet_03v3 ad=8.8p pd=40.88u as=8.8p ps=40.88u w=20u l=1u
D0 VSS FS_HIGH_P diode_nd2ps_03v3 pj=5.76u area=2.0736p
X23 PULLUP_N_BLEED_6 PULLUP_N_GATE VSS ppolyf_u_1k r_width=1u r_length=12.5u
X24 TERM_N_R TERM_GATE_N TERM_VCM VSS nfet_03v3 ad=8.8p pd=40.88u as=8.8p ps=40.88u w=20u l=0.28u
X25 VSS a_41852_148519# ESD_RAIL VSS nfet_06v0 ad=13.936p pd=54.12u as=13.936p ps=54.12u w=53.6u l=0.7u
X26 VSS a_41852_148519# ESD_RAIL VSS nfet_06v0 ad=13.936p pd=54.12u as=13.936p ps=54.12u w=53.6u l=0.7u
X27 VSS a_41852_148519# ESD_RAIL VSS nfet_06v0 ad=13.936p pd=54.12u as=13.936p ps=54.12u w=53.6u l=0.7u
X28 PULLUP_P_CONTROL_S VDD VSS VSS nfet_03v3 ad=1.76p pd=8.88u as=1.76p ps=8.88u w=4u l=0.28u
X29 TERM_P_R TERM_GATE_P TERM_VCM VSS nfet_03v3 ad=8.8p pd=40.88u as=8.8p ps=40.88u w=20u l=0.28u
X30 ESD_RAIL a_42245_90628# VSS VSS nfet_06v0 ad=13p pd=50.52u as=13p ps=50.52u w=50u l=0.7u
X31 VDD FS_P_GATE FS_P_WELL FS_P_WELL pfet_03v3 ad=6.16p pd=28.88u as=6.16p ps=28.88u w=14u l=0.28u
X32 PULLUP_N_OUT PULLUP_N_GATE PULLUP_N_WELL PULLUP_N_WELL pfet_03v3 ad=8.8p pd=40.88u as=8.8p ps=40.88u w=20u l=0.28u
X33 TERM_N_R TERM_GATE_N TERM_VCM VSS nfet_03v3 ad=8.8p pd=40.88u as=8.8p ps=40.88u w=20u l=0.28u
X34 HS_N_4 HS_N PAD_N VSS nfet_06v0 ad=8.8p pd=40.88u as=8.8p ps=40.88u w=20u l=0.7u
X35 ESD_RAIL a_42245_90628# VSS VSS nfet_06v0 ad=13p pd=50.52u as=13p ps=50.52u w=50u l=0.7u
X36 VDD FS_P_GATE FS_P_WELL FS_P_WELL pfet_03v3 ad=6.16p pd=28.88u as=6.16p ps=28.88u w=14u l=0.28u
X37 PULLUP_N_OUT PULLUP_N_GATE PULLUP_N_WELL PULLUP_N_WELL pfet_03v3 ad=8.8p pd=40.88u as=8.8p ps=40.88u w=20u l=0.28u
X38 VDD FS_N_GATE FS_N_WELL FS_N_WELL pfet_03v3 ad=6.16p pd=28.88u as=6.16p ps=28.88u w=14u l=0.28u
D1 PAD_N ESD_RAIL diode_pd2nw_06v0 pj=51.8u area=22.5p
X39 FS_N_GATE VDD FS_N_WELL FS_N_WELL pfet_03v3 ad=1.76p pd=8.88u as=1.76p ps=8.88u w=4u l=0.28u
X40 VDD FS_N_GATE FS_N_WELL FS_N_WELL pfet_03v3 ad=6.16p pd=28.88u as=6.16p ps=28.88u w=14u l=0.28u
X41 FS_P_OUT FS_P_GATE FS_P_WELL FS_P_WELL pfet_03v3 ad=6.16p pd=28.88u as=6.16p ps=28.88u w=14u l=0.28u
X42 ESD_RAIL a_41852_148519# VSS VSS nfet_06v0 ad=13.936p pd=54.12u as=13.936p ps=54.12u w=53.6u l=0.7u
X43 TERM_OR_N_S TERM_ENABLE VDD VDD pfet_03v3 ad=1.76p pd=8.88u as=1.76p ps=8.88u w=4u l=0.28u
X44 a_41005_131825# a_53878_132105# ESD_RAIL ppolyf_u r_width=0.8u r_length=63.855u
X45 VSS a_41852_148519# ESD_RAIL VSS nfet_06v0 ad=23.584p pd=0.10808m as=13.936p ps=54.12u w=53.6u l=0.7u
X46 ESD_RAIL a_41852_148519# VSS VSS nfet_06v0 ad=13.936p pd=54.12u as=13.936p ps=54.12u w=53.6u l=0.7u
X47 PULLUP_P_BLEED_1 PULLUP_P_BLEED_2 VSS ppolyf_u_1k r_width=1u r_length=12.5u
X48 VSS a_41852_148519# ESD_RAIL VSS nfet_06v0 ad=13.936p pd=54.12u as=13.936p ps=54.12u w=53.6u l=0.7u
X49 ESD_RAIL a_42245_90628# VSS VSS nfet_06v0 ad=13p pd=50.52u as=13p ps=50.52u w=50u l=0.7u
X50 ESD_RAIL a_41852_148519# VSS VSS nfet_06v0 ad=13.936p pd=54.12u as=13.936p ps=54.12u w=53.6u l=0.7u
X51 a_42245_90628# a_44789_117064# ESD_RAIL ESD_RAIL pfet_06v0 ad=1.3p pd=5.52u as=1.3p ps=5.52u w=5u l=0.7u
X52 PULLDOWN_P_R PULLDOWN_P VSS VSS nfet_03v3 ad=3.52p pd=16.88u as=3.52p ps=16.88u w=8u l=0.28u
X53 VSS a_42245_90628# ESD_RAIL VSS nfet_06v0 ad=13p pd=50.52u as=13p ps=50.52u w=50u l=0.7u
X54 ESD_RAIL a_42245_90628# VSS VSS nfet_06v0 ad=13p pd=50.52u as=13p ps=50.52u w=50u l=0.7u
X55 ESD_RAIL a_44789_117064# a_42245_90628# ESD_RAIL pfet_06v0 ad=1.3p pd=5.52u as=1.3p ps=5.52u w=5u l=0.7u
X56 a_42245_90628# a_44789_117064# ESD_RAIL ESD_RAIL pfet_06v0 ad=1.3p pd=5.52u as=1.3p ps=5.52u w=5u l=0.7u
D2 PAD_P ESD_RAIL diode_pd2nw_06v0 pj=51.8u area=22.5p
X57 VSS a_44789_117064# a_42245_90628# VSS nfet_06v0 ad=2.2p pd=10.88u as=1.3p ps=5.52u w=5u l=0.7u
X58 FS_P_OUT FS_P_GATE FS_P_WELL FS_P_WELL pfet_03v3 ad=6.16p pd=28.88u as=6.16p ps=28.88u w=14u l=0.28u
X59 VSS a_41852_148519# ESD_RAIL VSS nfet_06v0 ad=13.936p pd=54.12u as=13.936p ps=54.12u w=53.6u l=0.7u
X60 ESD_RAIL a_41852_148519# VSS VSS nfet_06v0 ad=13.936p pd=54.12u as=13.936p ps=54.12u w=53.6u l=0.7u
X61 ESD_RAIL a_42245_90628# VSS VSS nfet_06v0 ad=13p pd=50.52u as=13p ps=50.52u w=50u l=0.7u
X62 ESD_RAIL a_41852_148519# VSS VSS nfet_06v0 ad=13.936p pd=54.12u as=13.936p ps=54.12u w=53.6u l=0.7u
X63 VSS a_41852_148519# ESD_RAIL VSS nfet_06v0 ad=13.936p pd=54.12u as=13.936p ps=54.12u w=53.6u l=0.7u
X64 ESD_RAIL a_44789_117064# a_42245_90628# ESD_RAIL pfet_06v0 ad=1.3p pd=5.52u as=1.3p ps=5.52u w=5u l=0.7u
X65 ESD_RAIL a_42245_90628# VSS VSS nfet_06v0 ad=22p pd=0.10088m as=13p ps=50.52u w=50u l=0.7u
X66 VSS a_42245_90628# ESD_RAIL VSS nfet_06v0 ad=13p pd=50.52u as=13p ps=50.52u w=50u l=0.7u
X67 HS_P_9 HS_PBIAS VDD VDD pfet_03v3 ad=8.8p pd=40.88u as=8.8p ps=40.88u w=20u l=1u
X68 a_41005_132945# a_53878_133225# ESD_RAIL ppolyf_u r_width=0.8u r_length=63.855u
X69 ESD_RAIL a_41852_148519# VSS VSS nfet_06v0 ad=13.936p pd=54.12u as=13.936p ps=54.12u w=53.6u l=0.7u
X70 a_42245_90628# a_44789_117064# VSS VSS nfet_06v0 ad=1.3p pd=5.52u as=1.3p ps=5.52u w=5u l=0.7u
X71 ESD_RAIL a_44789_117064# a_42245_90628# ESD_RAIL pfet_06v0 ad=1.3p pd=5.52u as=1.3p ps=5.52u w=5u l=0.7u
X72 FS_P_OUT FS_P_GATE FS_P_WELL FS_P_WELL pfet_03v3 ad=6.16p pd=28.88u as=6.16p ps=28.88u w=14u l=0.28u
X73 VDD FS_N_GATE FS_N_WELL FS_N_WELL pfet_03v3 ad=6.16p pd=28.88u as=6.16p ps=28.88u w=14u l=0.28u
X74 HS_N_9 HS_N PAD_N VSS nfet_06v0 ad=8.8p pd=40.88u as=8.8p ps=40.88u w=20u l=0.7u
X75 VSS a_41852_148519# ESD_RAIL VSS nfet_06v0 ad=13.936p pd=54.12u as=13.936p ps=54.12u w=53.6u l=0.7u
X76 ESD_RAIL a_41852_148519# VSS VSS nfet_06v0 ad=13.936p pd=54.12u as=13.936p ps=54.12u w=53.6u l=0.7u
X77 ESD_RAIL a_41852_148519# VSS VSS nfet_06v0 ad=13.936p pd=54.12u as=13.936p ps=54.12u w=53.6u l=0.7u
X78 VSS a_41852_148519# ESD_RAIL VSS nfet_06v0 ad=23.584p pd=0.10808m as=13.936p ps=54.12u w=53.6u l=0.7u
X79 a_42245_90628# a_44789_117064# ESD_RAIL ESD_RAIL pfet_06v0 ad=1.3p pd=5.52u as=2.2p ps=10.88u w=5u l=0.7u
X80 ESD_RAIL a_41852_148519# VSS VSS nfet_06v0 ad=13.936p pd=54.12u as=13.936p ps=54.12u w=53.6u l=0.7u
X81 FS_P_OUT FS_P_GATE FS_P_WELL FS_P_WELL pfet_03v3 ad=6.16p pd=28.88u as=6.16p ps=28.88u w=14u l=0.28u
X82 a_43813_117064# a_41005_131545# VSS VSS nfet_06v0 ad=2.2p pd=10.88u as=2.2p ps=10.88u w=5u l=0.7u
X83 VSS a_41852_148519# ESD_RAIL VSS nfet_06v0 ad=13.936p pd=54.12u as=13.936p ps=54.12u w=53.6u l=0.7u
X84 VSS a_41852_148519# ESD_RAIL VSS nfet_06v0 ad=13.936p pd=54.12u as=13.936p ps=54.12u w=53.6u l=0.7u
X85 ESD_RAIL a_42245_90628# VSS VSS nfet_06v0 ad=13p pd=50.52u as=13p ps=50.52u w=50u l=0.7u
X86 VSS a_42245_90628# ESD_RAIL VSS nfet_06v0 ad=13p pd=50.52u as=22p ps=0.10088m w=50u l=0.7u
X87 a_42245_90628# a_44789_117064# VSS VSS nfet_06v0 ad=1.3p pd=5.52u as=1.3p ps=5.52u w=5u l=0.7u
X88 VSS a_41852_148519# ESD_RAIL VSS nfet_06v0 ad=13.936p pd=54.12u as=13.936p ps=54.12u w=53.6u l=0.7u
X89 HS_P_7 HS_PBIAS VDD VDD pfet_03v3 ad=8.8p pd=40.88u as=8.8p ps=40.88u w=20u l=1u
X90 VSS a_41852_148519# ESD_RAIL VSS nfet_06v0 ad=13.936p pd=54.12u as=13.936p ps=54.12u w=53.6u l=0.7u
X91 ESD_RAIL a_41852_148519# VSS VSS nfet_06v0 ad=13.936p pd=54.12u as=13.936p ps=54.12u w=53.6u l=0.7u
X92 VSS a_43813_117064# a_44789_117064# VSS nfet_06v0 ad=1.3p pd=5.52u as=1.3p ps=5.52u w=5u l=0.7u
X93 a_42245_90628# a_44789_117064# ESD_RAIL ESD_RAIL pfet_06v0 ad=1.3p pd=5.52u as=1.3p ps=5.52u w=5u l=0.7u
X94 HS_P_11 HS_P PAD_P VSS nfet_06v0 ad=8.8p pd=40.88u as=8.8p ps=40.88u w=20u l=0.7u
X95 VSS a_42245_90628# ESD_RAIL VSS nfet_06v0 ad=13p pd=50.52u as=22p ps=0.10088m w=50u l=0.7u
X96 PAD_P PULLDOWN_P_R VSS ppolyf_u_1k r_width=1u r_length=14.2u
X97 TERM_P_R TERM_GATE_P TERM_VCM VSS nfet_03v3 ad=8.8p pd=40.88u as=8.8p ps=40.88u w=20u l=0.28u
X98 PAD_P BYPASS_ENABLE RX_P VSS nfet_06v0 ad=8.8p pd=40.88u as=8.8p ps=40.88u w=20u l=0.7u
X99 HS_N_6 HS_N PAD_N VSS nfet_06v0 ad=8.8p pd=40.88u as=8.8p ps=40.88u w=20u l=0.7u
X100 a_41005_134065# a_53878_134345# ESD_RAIL ppolyf_u r_width=0.8u r_length=63.855u
X101 VSS a_41852_148519# ESD_RAIL VSS nfet_06v0 ad=23.584p pd=0.10808m as=13.936p ps=54.12u w=53.6u l=0.7u
X102 VDD FS_N_GATE FS_N_WELL FS_N_WELL pfet_03v3 ad=6.16p pd=28.88u as=6.16p ps=28.88u w=14u l=0.28u
X103 FS_P_OUT FS_P_GATE FS_P_WELL FS_P_WELL pfet_03v3 ad=6.16p pd=28.88u as=6.16p ps=28.88u w=14u l=0.28u
D3 PAD_N ESD_RAIL diode_pd2nw_06v0 pj=51.8u area=22.5p
X104 ESD_RAIL a_41852_148519# VSS VSS nfet_06v0 ad=13.936p pd=54.12u as=13.936p ps=54.12u w=53.6u l=0.7u
X105 ESD_RAIL a_42245_90628# VSS VSS nfet_06v0 ad=13p pd=50.52u as=13p ps=50.52u w=50u l=0.7u
X106 DIV_LOW_P DIV_ENABLE VSS VSS nfet_03v3 ad=8.8p pd=40.88u as=8.8p ps=40.88u w=20u l=0.28u
X107 ESD_RAIL a_41852_148519# VSS VSS nfet_06v0 ad=13.936p pd=54.12u as=13.936p ps=54.12u w=53.6u l=0.7u
X108 VDD FS_N_GATE FS_N_WELL FS_N_WELL pfet_03v3 ad=6.16p pd=28.88u as=6.16p ps=28.88u w=14u l=0.28u
X109 FS_P_OUT FS_P_GATE FS_P_WELL FS_P_WELL pfet_03v3 ad=6.16p pd=28.88u as=6.16p ps=28.88u w=14u l=0.28u
X110 VSS a_43813_117064# a_44789_117064# VSS nfet_06v0 ad=1.3p pd=5.52u as=1.3p ps=5.52u w=5u l=0.7u
X111 ESD_RAIL a_41852_148519# VSS VSS nfet_06v0 ad=13.936p pd=54.12u as=23.584p ps=0.10808m w=53.6u l=0.7u
D4 PAD_P ESD_RAIL diode_pd2nw_06v0 pj=51.8u area=22.5p
X112 HS_N_7 HS_N PAD_N VSS nfet_06v0 ad=8.8p pd=40.88u as=8.8p ps=40.88u w=20u l=0.7u
X113 FS_P_BLEED_6 FS_P_GATE VSS ppolyf_u_1k r_width=1u r_length=12.5u
X114 VSS a_42245_90628# ESD_RAIL VSS nfet_06v0 ad=13p pd=50.52u as=13p ps=50.52u w=50u l=0.7u
X115 VDD PULLUP_P_GATE PULLUP_P_WELL PULLUP_P_WELL pfet_03v3 ad=8.8p pd=40.88u as=8.8p ps=40.88u w=20u l=0.28u
X116 FS_P_OUT FS_P_GATE FS_P_WELL FS_P_WELL pfet_03v3 ad=6.16p pd=28.88u as=6.16p ps=28.88u w=14u l=0.28u
X117 ESD_RAIL a_42245_90628# VSS VSS nfet_06v0 ad=13p pd=50.52u as=13p ps=50.52u w=50u l=0.7u
X118 VSS a_41852_148519# ESD_RAIL VSS nfet_06v0 ad=13.936p pd=54.12u as=13.936p ps=54.12u w=53.6u l=0.7u
X119 TERM_P_R DIFF_ENABLE TERM_N_R VSS nfet_03v3 ad=8.8p pd=40.88u as=8.8p ps=40.88u w=20u l=0.28u
X120 ESD_RAIL a_41852_148519# VSS VSS nfet_06v0 ad=13.936p pd=54.12u as=13.936p ps=54.12u w=53.6u l=0.7u
X121 ESD_RAIL a_41852_148519# VSS VSS nfet_06v0 ad=13.936p pd=54.12u as=13.936p ps=54.12u w=53.6u l=0.7u
X122 VDD FS_N_GATE FS_N_WELL FS_N_WELL pfet_03v3 ad=6.16p pd=28.88u as=6.16p ps=28.88u w=14u l=0.28u
D5 VSS TERM_ENABLE diode_nd2ps_03v3 pj=7.56u area=3.5721p
X123 TERM_OR_N_B TERM_ENABLE VSS VSS nfet_03v3 ad=0.88p pd=4.88u as=0.88p ps=4.88u w=2u l=0.28u
X124 HS_N_2 HS_N PAD_N VSS nfet_06v0 ad=8.8p pd=40.88u as=8.8p ps=40.88u w=20u l=0.7u
X125 VSS a_41852_148519# ESD_RAIL VSS nfet_06v0 ad=13.936p pd=54.12u as=13.936p ps=54.12u w=53.6u l=0.7u
X126 ESD_RAIL a_42245_90628# VSS VSS nfet_06v0 ad=13p pd=50.52u as=13p ps=50.52u w=50u l=0.7u
X127 HS_N_6 HS_PBIAS VDD VDD pfet_03v3 ad=8.8p pd=40.88u as=8.8p ps=40.88u w=20u l=1u
X128 PULLUP_N_OUT PULLUP_N_GATE PULLUP_N_WELL PULLUP_N_WELL pfet_03v3 ad=8.8p pd=40.88u as=8.8p ps=40.88u w=20u l=0.28u
X129 VSS a_41852_148519# ESD_RAIL VSS nfet_06v0 ad=13.936p pd=54.12u as=13.936p ps=54.12u w=53.6u l=0.7u
X130 HS_N_8 HS_PBIAS VDD VDD pfet_03v3 ad=8.8p pd=40.88u as=8.8p ps=40.88u w=20u l=1u
X131 FS_P_BLEED_0 FS_P_BLEED_1 VSS ppolyf_u_1k r_width=1u r_length=12.5u
X132 PULLUP_N_BLEED_3 PULLUP_N_BLEED_4 VSS ppolyf_u_1k r_width=1u r_length=12.5u
X133 FS_P_OUT FS_P_GATE FS_P_WELL FS_P_WELL pfet_03v3 ad=6.16p pd=28.88u as=6.16p ps=28.88u w=14u l=0.28u
X134 FS_N_OUT PAD_N VSS ppolyf_s r_width=2u r_length=3.5u
X135 VSS a_41852_148519# ESD_RAIL VSS nfet_06v0 ad=13.936p pd=54.12u as=13.936p ps=54.12u w=53.6u l=0.7u
X136 ESD_RAIL a_41852_148519# VSS VSS nfet_06v0 ad=13.936p pd=54.12u as=13.936p ps=54.12u w=53.6u l=0.7u
X137 a_41005_131545# VSS cap_mim_2f0_m4m5_noshield c_width=14u c_length=14u
X138 ESD_RAIL a_41852_148519# VSS VSS nfet_06v0 ad=13.936p pd=54.12u as=13.936p ps=54.12u w=53.6u l=0.7u
X139 TERM_P_R DIFF_ENABLE TERM_N_R VSS nfet_03v3 ad=8.8p pd=40.88u as=8.8p ps=40.88u w=20u l=0.28u
X140 FS_P_BLEED_2 FS_P_BLEED_3 VSS ppolyf_u_1k r_width=1u r_length=12.5u
X141 TERM_OR_P_S TERM_ENABLE VDD VDD pfet_03v3 ad=1.76p pd=8.88u as=1.76p ps=8.88u w=4u l=0.28u
X142 TERM_GATE_N TERM_OR_N_B VDD VDD pfet_03v3 ad=3.52p pd=16.88u as=3.52p ps=16.88u w=8u l=0.28u
X143 VDD PULLUP_P_GATE PULLUP_P_WELL PULLUP_P_WELL pfet_03v3 ad=8.8p pd=40.88u as=8.8p ps=40.88u w=20u l=0.28u
X144 FS_P_OUT FS_P_GATE FS_P_WELL FS_P_WELL pfet_03v3 ad=6.16p pd=28.88u as=6.16p ps=28.88u w=14u l=0.28u
X145 ESD_RAIL a_41852_148519# VSS VSS nfet_06v0 ad=13.936p pd=54.12u as=13.936p ps=54.12u w=53.6u l=0.7u
X146 VDD FS_N_GATE FS_N_WELL FS_N_WELL pfet_03v3 ad=6.16p pd=28.88u as=6.16p ps=28.88u w=14u l=0.28u
X147 TERM_N_R TERM_GATE_N TERM_VCM VSS nfet_03v3 ad=8.8p pd=40.88u as=8.8p ps=40.88u w=20u l=0.28u
X148 HS_N_13 HS_N PAD_N VSS nfet_06v0 ad=8.8p pd=40.88u as=8.8p ps=40.88u w=20u l=0.7u
X149 FS_P_OUT FS_P_GATE FS_P_WELL FS_P_WELL pfet_03v3 ad=6.16p pd=28.88u as=6.16p ps=28.88u w=14u l=0.28u
X150 HS_N_2 HS_PBIAS VDD VDD pfet_03v3 ad=8.8p pd=40.88u as=8.8p ps=40.88u w=20u l=1u
X151 VSS a_42245_90628# ESD_RAIL VSS nfet_06v0 ad=13p pd=50.52u as=13p ps=50.52u w=50u l=0.7u
X152 VCM_LOW_OK TERM_VCM VDD VDD pfet_03v3 ad=0.88p pd=4.88u as=0.88p ps=4.88u w=2u l=0.28u
X153 VSS a_41852_148519# ESD_RAIL VSS nfet_06v0 ad=13.936p pd=54.12u as=13.936p ps=54.12u w=53.6u l=0.7u
X154 VSS a_41852_148519# ESD_RAIL VSS nfet_06v0 ad=13.936p pd=54.12u as=13.936p ps=54.12u w=53.6u l=0.7u
X155 PULLUP_N_BLEED_1 PULLUP_N_BLEED_2 VSS ppolyf_u_1k r_width=1u r_length=12.5u
X156 ESD_RAIL a_41852_148519# VSS VSS nfet_06v0 ad=13.936p pd=54.12u as=13.936p ps=54.12u w=53.6u l=0.7u
X157 ESD_RAIL a_42245_90628# VSS VSS nfet_06v0 ad=13p pd=50.52u as=13p ps=50.52u w=50u l=0.7u
X158 FS_N_BLEED_6 FS_N_GATE VSS ppolyf_u_1k r_width=1u r_length=12.5u
X159 HS_P_11 HS_PBIAS VDD VDD pfet_03v3 ad=8.8p pd=40.88u as=8.8p ps=40.88u w=20u l=1u
X160 ESD_RAIL a_41852_148519# VSS VSS nfet_06v0 ad=13.936p pd=54.12u as=13.936p ps=54.12u w=53.6u l=0.7u
X161 VSS a_41852_148519# ESD_RAIL VSS nfet_06v0 ad=23.584p pd=0.10808m as=13.936p ps=54.12u w=53.6u l=0.7u
X162 VSS a_41852_148519# ESD_RAIL VSS nfet_06v0 ad=13.936p pd=54.12u as=13.936p ps=54.12u w=53.6u l=0.7u
X163 VSS a_41852_148519# ESD_RAIL VSS nfet_06v0 ad=13.936p pd=54.12u as=13.936p ps=54.12u w=53.6u l=0.7u
X164 ESD_RAIL a_41852_148519# VSS VSS nfet_06v0 ad=13.936p pd=54.12u as=13.936p ps=54.12u w=53.6u l=0.7u
X165 ESD_RAIL a_41852_148519# VSS VSS nfet_06v0 ad=13.936p pd=54.12u as=23.584p ps=0.10808m w=53.6u l=0.7u
X166 VSS a_42245_90628# ESD_RAIL VSS nfet_06v0 ad=13p pd=50.52u as=13p ps=50.52u w=50u l=0.7u
X167 ESD_RAIL a_42245_90628# VSS VSS nfet_06v0 ad=13p pd=50.52u as=13p ps=50.52u w=50u l=0.7u
X168 FS_P_OUT FS_P_GATE FS_P_WELL FS_P_WELL pfet_03v3 ad=6.16p pd=28.88u as=6.16p ps=28.88u w=14u l=0.28u
X169 FS_N_OUT FS_N_GATE FS_N_WELL FS_N_WELL pfet_03v3 ad=6.16p pd=28.88u as=6.16p ps=28.88u w=14u l=0.28u
X170 PULLUP_P_OUT PAD_P VSS ppolyf_u_1k r_width=1u r_length=1.18u
X171 VSS a_41852_148519# ESD_RAIL VSS nfet_06v0 ad=13.936p pd=54.12u as=13.936p ps=54.12u w=53.6u l=0.7u
X172 FS_P_OUT FS_P_GATE FS_P_WELL FS_P_WELL pfet_03v3 ad=6.16p pd=28.88u as=6.16p ps=28.88u w=14u l=0.28u
X173 VSS a_41852_148519# ESD_RAIL VSS nfet_06v0 ad=23.584p pd=0.10808m as=13.936p ps=54.12u w=53.6u l=0.7u
X174 FS_N_OUT FS_N_GATE FS_N_WELL FS_N_WELL pfet_03v3 ad=6.16p pd=28.88u as=6.16p ps=28.88u w=14u l=0.28u
X175 FS_P_OUT FS_P_GATE FS_P_WELL FS_P_WELL pfet_03v3 ad=6.16p pd=28.88u as=6.16p ps=28.88u w=14u l=0.28u
X176 HS_P_3 HS_PBIAS VDD VDD pfet_03v3 ad=8.8p pd=40.88u as=8.8p ps=40.88u w=20u l=1u
X177 FS_N_BLEED_0 FS_N_BLEED_1 VSS ppolyf_u_1k r_width=1u r_length=12.5u
X178 TERM_OR_N_NS VCM_LOW_OK VSS VSS nfet_03v3 ad=1.76p pd=8.88u as=1.76p ps=8.88u w=4u l=0.28u
D6 VSS PULLUP_P diode_nd2ps_03v3 pj=6.2u area=2.4025p
X179 ESD_RAIL a_42245_90628# VSS VSS nfet_06v0 ad=13p pd=50.52u as=13p ps=50.52u w=50u l=0.7u
X180 VSS a_41852_148519# ESD_RAIL VSS nfet_06v0 ad=13.936p pd=54.12u as=13.936p ps=54.12u w=53.6u l=0.7u
X181 VSS a_41852_148519# ESD_RAIL VSS nfet_06v0 ad=13.936p pd=54.12u as=13.936p ps=54.12u w=53.6u l=0.7u
X182 FS_P_OUT FS_P_GATE FS_P_WELL FS_P_WELL pfet_03v3 ad=6.16p pd=28.88u as=6.16p ps=28.88u w=14u l=0.28u
X183 VSS a_42245_90628# ESD_RAIL VSS nfet_06v0 ad=13p pd=50.52u as=13p ps=50.52u w=50u l=0.7u
X184 ESD_RAIL a_41852_148519# VSS VSS nfet_06v0 ad=13.936p pd=54.12u as=13.936p ps=54.12u w=53.6u l=0.7u
X185 ESD_RAIL a_41852_148519# VSS VSS nfet_06v0 ad=13.936p pd=54.12u as=13.936p ps=54.12u w=53.6u l=0.7u
X186 FS_P_OUT FS_P_GATE FS_P_WELL FS_P_WELL pfet_03v3 ad=6.16p pd=28.88u as=6.16p ps=28.88u w=14u l=0.28u
X187 FS_N_OUT FS_N_GATE FS_N_WELL FS_N_WELL pfet_03v3 ad=6.16p pd=28.88u as=6.16p ps=28.88u w=14u l=0.28u
X188 VDD PULLUP_N_GATE PULLUP_N_WELL PULLUP_N_WELL pfet_03v3 ad=8.8p pd=40.88u as=8.8p ps=40.88u w=20u l=0.28u
X189 ESD_RAIL a_42245_90628# VSS VSS nfet_06v0 ad=13p pd=50.52u as=13p ps=50.52u w=50u l=0.7u
D7 VSS ESD_RAIL diode_nd2ps_06v0 pj=82u area=40p
X190 ESD_RAIL a_41852_148519# VSS VSS nfet_06v0 ad=13.936p pd=54.12u as=13.936p ps=54.12u w=53.6u l=0.7u
X191 FS_N_OUT FS_N_GATE FS_N_WELL FS_N_WELL pfet_03v3 ad=6.16p pd=28.88u as=6.16p ps=28.88u w=14u l=0.28u
X192 a_44789_117064# a_43813_117064# VSS VSS nfet_06v0 ad=1.3p pd=5.52u as=2.2p ps=10.88u w=5u l=0.7u
X193 ESD_RAIL a_41852_148519# VSS VSS nfet_06v0 ad=13.936p pd=54.12u as=13.936p ps=54.12u w=53.6u l=0.7u
X194 VSS a_42245_90628# ESD_RAIL VSS nfet_06v0 ad=13p pd=50.52u as=13p ps=50.52u w=50u l=0.7u
X195 HS_P_13 HS_PBIAS VDD VDD pfet_03v3 ad=8.8p pd=40.88u as=8.8p ps=40.88u w=20u l=1u
D8 VSS ESD_RAIL diode_nd2ps_06v0 pj=82u area=40p
X196 ESD_RAIL a_41852_148519# VSS VSS nfet_06v0 ad=13.936p pd=54.12u as=13.936p ps=54.12u w=53.6u l=0.7u
X197 VSS a_41852_148519# ESD_RAIL VSS nfet_06v0 ad=13.936p pd=54.12u as=13.936p ps=54.12u w=53.6u l=0.7u
X198 TERM_P_R DIFF_ENABLE TERM_N_R VSS nfet_03v3 ad=8.8p pd=40.88u as=8.8p ps=40.88u w=20u l=0.28u
X199 PAD_N DIV_N VSS ppolyf_u_1k r_width=1u r_length=2u
X200 TERM_GATE_N_BLEED_1 TERM_GATE_N_BLEED_2 VSS ppolyf_u_1k r_width=1u r_length=12.5u
X201 a_41852_148519# VSS VSS ppolyf_u_1k_6p0 r_width=1u r_length=6u
X202 VSS a_41852_148519# ESD_RAIL VSS nfet_06v0 ad=13.936p pd=54.12u as=13.936p ps=54.12u w=53.6u l=0.7u
X203 ESD_RAIL a_41852_148519# VSS VSS nfet_06v0 ad=13.936p pd=54.12u as=13.936p ps=54.12u w=53.6u l=0.7u
X204 PULLUP_P_BLEED_4 PULLUP_P_BLEED_5 VSS ppolyf_u_1k r_width=1u r_length=12.5u
X205 FS_N_OUT FS_N_GATE FS_N_WELL FS_N_WELL pfet_03v3 ad=6.16p pd=28.88u as=6.16p ps=28.88u w=14u l=0.28u
X206 ESD_RAIL a_42245_90628# VSS VSS nfet_06v0 ad=13p pd=50.52u as=13p ps=50.52u w=50u l=0.7u
X207 VSS a_41852_148519# ESD_RAIL VSS nfet_06v0 ad=13.936p pd=54.12u as=13.936p ps=54.12u w=53.6u l=0.7u
X208 FS_N_OUT FS_N_GATE FS_N_WELL FS_N_WELL pfet_03v3 ad=6.16p pd=28.88u as=6.16p ps=28.88u w=14u l=0.28u
X209 FS_P_OUT FS_P_GATE FS_P_WELL FS_P_WELL pfet_03v3 ad=6.16p pd=28.88u as=6.16p ps=28.88u w=14u l=0.28u
X210 VSS a_41852_148519# ESD_RAIL VSS nfet_06v0 ad=23.584p pd=0.10808m as=13.936p ps=54.12u w=53.6u l=0.7u
X211 VSS a_41852_148519# ESD_RAIL VSS nfet_06v0 ad=13.936p pd=54.12u as=13.936p ps=54.12u w=53.6u l=0.7u
X212 FS_N_CONTROL_S VDD VSS VSS nfet_03v3 ad=1.76p pd=8.88u as=1.76p ps=8.88u w=4u l=0.28u
X213 FS_N_OUT FS_N_GATE FS_N_WELL FS_N_WELL pfet_03v3 ad=6.16p pd=28.88u as=6.16p ps=28.88u w=14u l=0.28u
X214 a_41005_131825# a_53878_131545# ESD_RAIL ppolyf_u r_width=0.8u r_length=63.855u
X215 PULLUP_N_BLEED_5 PULLUP_N_BLEED_6 VSS ppolyf_u_1k r_width=1u r_length=12.5u
X216 ESD_RAIL a_41852_148519# VSS VSS nfet_06v0 ad=13.936p pd=54.12u as=23.584p ps=0.10808m w=53.6u l=0.7u
X217 VSS a_41852_148519# ESD_RAIL VSS nfet_06v0 ad=13.936p pd=54.12u as=13.936p ps=54.12u w=53.6u l=0.7u
X218 PULLUP_P_GATE PULLUP_P PULLUP_P_CONTROL_S VSS nfet_06v0 ad=0.88p pd=4.88u as=0.88p ps=4.88u w=2u l=0.7u
X219 ESD_RAIL a_41852_148519# VSS VSS nfet_06v0 ad=13.936p pd=54.12u as=13.936p ps=54.12u w=53.6u l=0.7u
X220 VCM_LOW_OK TERM_VCM VSS VSS nfet_03v3 ad=3.52p pd=16.88u as=3.52p ps=16.88u w=8u l=0.28u
X221 TERM_OR_P_B VCM_LOW_OK TERM_OR_P_S VDD pfet_03v3 ad=1.76p pd=8.88u as=1.76p ps=8.88u w=4u l=0.28u
X222 ESD_RAIL a_41852_148519# VSS VSS nfet_06v0 ad=13.936p pd=54.12u as=13.936p ps=54.12u w=53.6u l=0.7u
X223 VSS a_41852_148519# ESD_RAIL VSS nfet_06v0 ad=13.936p pd=54.12u as=13.936p ps=54.12u w=53.6u l=0.7u
X224 TERM_GATE_P_BLEED_2 VSS VSS ppolyf_u_1k r_width=1u r_length=12.5u
X225 FS_N_OUT FS_N_GATE FS_N_WELL FS_N_WELL pfet_03v3 ad=6.16p pd=28.88u as=6.16p ps=28.88u w=14u l=0.28u
X226 ESD_RAIL a_41852_148519# VSS VSS nfet_06v0 ad=13.936p pd=54.12u as=13.936p ps=54.12u w=53.6u l=0.7u
X227 HS_N_11 HS_PBIAS VDD VDD pfet_03v3 ad=8.8p pd=40.88u as=8.8p ps=40.88u w=20u l=1u
D9 VSS FS_LOW_N diode_nd2ps_03v3 pj=2.4u area=0.36p
X228 VSS a_42245_90628# ESD_RAIL VSS nfet_06v0 ad=13p pd=50.52u as=13p ps=50.52u w=50u l=0.7u
X229 VSS a_41852_148519# ESD_RAIL VSS nfet_06v0 ad=13.936p pd=54.12u as=13.936p ps=54.12u w=53.6u l=0.7u
X230 ESD_RAIL a_44789_117064# a_42245_90628# ESD_RAIL pfet_06v0 ad=1.3p pd=5.52u as=1.3p ps=5.52u w=5u l=0.7u
X231 VSS a_41852_148519# ESD_RAIL VSS nfet_06v0 ad=13.936p pd=54.12u as=13.936p ps=54.12u w=53.6u l=0.7u
X232 VSS a_41852_148519# ESD_RAIL VSS nfet_06v0 ad=13.936p pd=54.12u as=13.936p ps=54.12u w=53.6u l=0.7u
X233 a_41005_132945# a_53878_132665# ESD_RAIL ppolyf_u r_width=0.8u r_length=63.855u
D10 VSS PAD_P diode_nd2ps_06v0 pj=51.8u area=22.5p
X234 HS_P_10 HS_P PAD_P VSS nfet_06v0 ad=8.8p pd=40.88u as=8.8p ps=40.88u w=20u l=0.7u
X235 FS_N_OUT FS_N_GATE FS_N_WELL FS_N_WELL pfet_03v3 ad=6.16p pd=28.88u as=6.16p ps=28.88u w=14u l=0.28u
X236 ESD_RAIL a_41852_148519# VSS VSS nfet_06v0 ad=13.936p pd=54.12u as=13.936p ps=54.12u w=53.6u l=0.7u
X237 PAD_N PULLDOWN_N_R VSS ppolyf_u_1k r_width=1u r_length=14.2u
X238 TERM_P_R TERM_GATE_P TERM_VCM VSS nfet_03v3 ad=8.8p pd=40.88u as=8.8p ps=40.88u w=20u l=0.28u
X239 ESD_RAIL a_42245_90628# VSS VSS nfet_06v0 ad=13p pd=50.52u as=13p ps=50.52u w=50u l=0.7u
X240 PAD_P BYPASS_ENABLE RX_P VSS nfet_06v0 ad=8.8p pd=40.88u as=8.8p ps=40.88u w=20u l=0.7u
X241 FS_N_OUT FS_N_GATE FS_N_WELL FS_N_WELL pfet_03v3 ad=6.16p pd=28.88u as=6.16p ps=28.88u w=14u l=0.28u
X242 HS_P_5 HS_P PAD_P VSS nfet_06v0 ad=8.8p pd=40.88u as=8.8p ps=40.88u w=20u l=0.7u
X243 ESD_RAIL a_41852_148519# VSS VSS nfet_06v0 ad=13.936p pd=54.12u as=13.936p ps=54.12u w=53.6u l=0.7u
X244 VSS a_42245_90628# ESD_RAIL VSS nfet_06v0 ad=13p pd=50.52u as=13p ps=50.52u w=50u l=0.7u
X245 VSS a_41852_148519# ESD_RAIL VSS nfet_06v0 ad=13.936p pd=54.12u as=13.936p ps=54.12u w=53.6u l=0.7u
X246 DIV_P DIV_ENABLE RX_P VSS nfet_06v0 ad=8.8p pd=40.88u as=8.8p ps=40.88u w=20u l=0.7u
X247 VSS a_41852_148519# ESD_RAIL VSS nfet_06v0 ad=13.936p pd=54.12u as=13.936p ps=54.12u w=53.6u l=0.7u
X248 VSS a_42245_90628# ESD_RAIL VSS nfet_06v0 ad=13p pd=50.52u as=13p ps=50.52u w=50u l=0.7u
X249 ESD_RAIL a_41852_148519# VSS VSS nfet_06v0 ad=13.936p pd=54.12u as=23.584p ps=0.10808m w=53.6u l=0.7u
X250 ESD_RAIL a_41852_148519# VSS VSS nfet_06v0 ad=13.936p pd=54.12u as=23.584p ps=0.10808m w=53.6u l=0.7u
X251 ESD_RAIL a_41852_148519# VSS VSS nfet_06v0 ad=13.936p pd=54.12u as=13.936p ps=54.12u w=53.6u l=0.7u
X252 HS_P_6 HS_P PAD_P VSS nfet_06v0 ad=8.8p pd=40.88u as=8.8p ps=40.88u w=20u l=0.7u
X253 FS_N_OUT FS_N_GATE FS_N_WELL FS_N_WELL pfet_03v3 ad=6.16p pd=28.88u as=6.16p ps=28.88u w=14u l=0.28u
X254 ESD_RAIL a_42245_90628# VSS VSS nfet_06v0 ad=13p pd=50.52u as=13p ps=50.52u w=50u l=0.7u
X255 VSS a_41852_148519# ESD_RAIL VSS nfet_06v0 ad=13.936p pd=54.12u as=13.936p ps=54.12u w=53.6u l=0.7u
X256 VSS a_41852_148519# ESD_RAIL VSS nfet_06v0 ad=13.936p pd=54.12u as=13.936p ps=54.12u w=53.6u l=0.7u
X257 VSS a_41852_148519# ESD_RAIL VSS nfet_06v0 ad=13.936p pd=54.12u as=13.936p ps=54.12u w=53.6u l=0.7u
X258 a_42245_90628# a_44789_117064# ESD_RAIL ESD_RAIL pfet_06v0 ad=1.3p pd=5.52u as=1.3p ps=5.52u w=5u l=0.7u
X259 a_43813_117064# a_41005_131545# ESD_RAIL ESD_RAIL pfet_06v0 ad=1.3p pd=5.52u as=1.3p ps=5.52u w=5u l=0.7u
X260 VSS a_41852_148519# ESD_RAIL VSS nfet_06v0 ad=13.936p pd=54.12u as=13.936p ps=54.12u w=53.6u l=0.7u
X261 FS_N_OUT FS_N_GATE FS_N_WELL FS_N_WELL pfet_03v3 ad=6.16p pd=28.88u as=6.16p ps=28.88u w=14u l=0.28u
X262 ESD_RAIL a_41852_148519# VSS VSS nfet_06v0 ad=13.936p pd=54.12u as=13.936p ps=54.12u w=53.6u l=0.7u
X263 ESD_RAIL a_41852_148519# VSS VSS nfet_06v0 ad=13.936p pd=54.12u as=13.936p ps=54.12u w=53.6u l=0.7u
X264 VSS a_41852_148519# ESD_RAIL VSS nfet_06v0 ad=13.936p pd=54.12u as=13.936p ps=54.12u w=53.6u l=0.7u
X265 VDD PULLUP_N_GATE PULLUP_N_WELL PULLUP_N_WELL pfet_03v3 ad=8.8p pd=40.88u as=8.8p ps=40.88u w=20u l=0.28u
X266 TERM_P_R TERM_GATE_P TERM_VCM VSS nfet_03v3 ad=8.8p pd=40.88u as=8.8p ps=40.88u w=20u l=0.28u
X267 ESD_RAIL a_41852_148519# VSS VSS nfet_06v0 ad=13.936p pd=54.12u as=23.584p ps=0.10808m w=53.6u l=0.7u
X268 ESD_RAIL a_41852_148519# VSS VSS nfet_06v0 ad=13.936p pd=54.12u as=23.584p ps=0.10808m w=53.6u l=0.7u
X269 a_44789_117064# a_43813_117064# ESD_RAIL ESD_RAIL pfet_06v0 ad=2.2p pd=10.88u as=1.3p ps=5.52u w=5u l=0.7u
X270 ESD_RAIL a_41852_148519# VSS VSS nfet_06v0 ad=13.936p pd=54.12u as=13.936p ps=54.12u w=53.6u l=0.7u
X271 HS_P_3 HS_P PAD_P VSS nfet_06v0 ad=8.8p pd=40.88u as=8.8p ps=40.88u w=20u l=0.7u
X272 FS_P_WELL FS_P_BLEED_0 VSS ppolyf_u_1k r_width=1u r_length=12.5u
X273 VDD FS_P_GATE FS_P_WELL FS_P_WELL pfet_03v3 ad=6.16p pd=28.88u as=6.16p ps=28.88u w=14u l=0.28u
D11 VSS PAD_N diode_nd2ps_06v0 pj=51.8u area=22.5p
X274 ESD_RAIL a_42245_90628# VSS VSS nfet_06v0 ad=13p pd=50.52u as=13p ps=50.52u w=50u l=0.7u
X275 VSS a_41852_148519# ESD_RAIL VSS nfet_06v0 ad=23.584p pd=0.10808m as=13.936p ps=54.12u w=53.6u l=0.7u
X276 FS_P_BLEED_1 FS_P_BLEED_2 VSS ppolyf_u_1k r_width=1u r_length=12.5u
X277 VDD FS_P_GATE FS_P_WELL FS_P_WELL pfet_03v3 ad=6.16p pd=28.88u as=6.16p ps=28.88u w=14u l=0.28u
X278 ESD_RAIL a_41852_148519# VSS VSS nfet_06v0 ad=13.936p pd=54.12u as=13.936p ps=54.12u w=53.6u l=0.7u
X279 PULLUP_P_OUT PULLUP_P_GATE PULLUP_P_WELL PULLUP_P_WELL pfet_03v3 ad=8.8p pd=40.88u as=8.8p ps=40.88u w=20u l=0.28u
X280 VSS a_42245_90628# ESD_RAIL VSS nfet_06v0 ad=13p pd=50.52u as=13p ps=50.52u w=50u l=0.7u
X281 VSS ESD_RAIL VSS ppolyf_u_1k_6p0 r_width=1u r_length=9.98874m
X282 VSS a_41852_148519# ESD_RAIL VSS nfet_06v0 ad=13.936p pd=54.12u as=13.936p ps=54.12u w=53.6u l=0.7u
X283 TERM_N_R TERM_GATE_N TERM_VCM VSS nfet_03v3 ad=8.8p pd=40.88u as=8.8p ps=40.88u w=20u l=0.28u
X284 ESD_RAIL a_41852_148519# VSS VSS nfet_06v0 ad=13.936p pd=54.12u as=23.584p ps=0.10808m w=53.6u l=0.7u
X285 HS_P_12 HS_P PAD_P VSS nfet_06v0 ad=8.8p pd=40.88u as=8.8p ps=40.88u w=20u l=0.7u
X286 VSS a_41852_148519# ESD_RAIL VSS nfet_06v0 ad=13.936p pd=54.12u as=13.936p ps=54.12u w=53.6u l=0.7u
X287 FS_N_OUT FS_N_GATE FS_N_WELL FS_N_WELL pfet_03v3 ad=6.16p pd=28.88u as=6.16p ps=28.88u w=14u l=0.28u
X288 ESD_RAIL a_44789_117064# a_42245_90628# ESD_RAIL pfet_06v0 ad=2.2p pd=10.88u as=1.3p ps=5.52u w=5u l=0.7u
X289 a_42245_90628# a_44789_117064# ESD_RAIL ESD_RAIL pfet_06v0 ad=1.3p pd=5.52u as=1.3p ps=5.52u w=5u l=0.7u
X290 VSS a_42245_90628# ESD_RAIL VSS nfet_06v0 ad=13p pd=50.52u as=13p ps=50.52u w=50u l=0.7u
X291 PAD_N TERM_N_R VSS ppolyf_u r_width=16u r_length=1.3u
X292 HS_N_1 HS_PBIAS VDD VDD pfet_03v3 ad=8.8p pd=40.88u as=8.8p ps=40.88u w=20u l=1u
X293 VSS a_41852_148519# ESD_RAIL VSS nfet_06v0 ad=13.936p pd=54.12u as=13.936p ps=54.12u w=53.6u l=0.7u
X294 ESD_RAIL a_41852_148519# VSS VSS nfet_06v0 ad=13.936p pd=54.12u as=13.936p ps=54.12u w=53.6u l=0.7u
X295 PULLUP_N_GATE PULLUP_N PULLUP_N_CONTROL_S VSS nfet_06v0 ad=0.88p pd=4.88u as=0.88p ps=4.88u w=2u l=0.7u
X296 VSS a_41852_148519# ESD_RAIL VSS nfet_06v0 ad=13.936p pd=54.12u as=13.936p ps=54.12u w=53.6u l=0.7u
X297 FS_N_BLEED_1 FS_N_BLEED_2 VSS ppolyf_u_1k r_width=1u r_length=12.5u
X298 TERM_OR_N_B VCM_LOW_OK TERM_OR_N_S VDD pfet_03v3 ad=1.76p pd=8.88u as=1.76p ps=8.88u w=4u l=0.28u
X299 DIV_N DIV_ENABLE RX_N VSS nfet_06v0 ad=8.8p pd=40.88u as=8.8p ps=40.88u w=20u l=0.7u
X300 a_41005_134065# a_53878_133785# ESD_RAIL ppolyf_u r_width=0.8u r_length=63.855u
X301 FS_P_GATE FS_HIGH_P FS_P_CONTROL_S VSS nfet_06v0 ad=0.88p pd=4.88u as=0.88p ps=4.88u w=2u l=0.7u
X302 ESD_RAIL a_41852_148519# VSS VSS nfet_06v0 ad=13.936p pd=54.12u as=13.936p ps=54.12u w=53.6u l=0.7u
X303 VDD FS_P_GATE FS_P_WELL FS_P_WELL pfet_03v3 ad=6.16p pd=28.88u as=6.16p ps=28.88u w=14u l=0.28u
X304 HS_P_10 HS_PBIAS VDD VDD pfet_03v3 ad=8.8p pd=40.88u as=8.8p ps=40.88u w=20u l=1u
X305 VSS a_42245_90628# ESD_RAIL VSS nfet_06v0 ad=13p pd=50.52u as=13p ps=50.52u w=50u l=0.7u
X306 ESD_RAIL a_41852_148519# VSS VSS nfet_06v0 ad=13.936p pd=54.12u as=13.936p ps=54.12u w=53.6u l=0.7u
X307 ESD_RAIL a_41852_148519# VSS VSS nfet_06v0 ad=13.936p pd=54.12u as=13.936p ps=54.12u w=53.6u l=0.7u
X308 ESD_RAIL a_41852_148519# VSS VSS nfet_06v0 ad=13.936p pd=54.12u as=13.936p ps=54.12u w=53.6u l=0.7u
X309 VSS a_42245_90628# ESD_RAIL VSS nfet_06v0 ad=13p pd=50.52u as=13p ps=50.52u w=50u l=0.7u
X310 ESD_RAIL a_44789_117064# a_42245_90628# ESD_RAIL pfet_06v0 ad=1.3p pd=5.52u as=1.3p ps=5.52u w=5u l=0.7u
X311 TERM_N_R TERM_GATE_N TERM_VCM VSS nfet_03v3 ad=8.8p pd=40.88u as=8.8p ps=40.88u w=20u l=0.28u
X312 VSS a_41852_148519# ESD_RAIL VSS nfet_06v0 ad=13.936p pd=54.12u as=13.936p ps=54.12u w=53.6u l=0.7u
X313 VSS RX_P VSS ppolyf_u_1k_6p0 r_width=1u r_length=0.31954m
X314 ESD_RAIL a_41852_148519# VSS VSS nfet_06v0 ad=13.936p pd=54.12u as=23.584p ps=0.10808m w=53.6u l=0.7u
X315 ESD_RAIL a_41852_148519# cap_mim_2f0_m4m5_noshield c_width=90u c_length=90u
X316 ESD_RAIL a_42245_90628# VSS VSS nfet_06v0 ad=13p pd=50.52u as=13p ps=50.52u w=50u l=0.7u
X317 ESD_RAIL a_41852_148519# VSS VSS nfet_06v0 ad=13.936p pd=54.12u as=13.936p ps=54.12u w=53.6u l=0.7u
D12 VSS ESD_RAIL diode_nd2ps_06v0 pj=82u area=40p
X318 VDD FS_P_GATE FS_P_WELL FS_P_WELL pfet_03v3 ad=6.16p pd=28.88u as=6.16p ps=28.88u w=14u l=0.28u
X319 ESD_RAIL VSS cap_mim_2f0_m4m5_noshield c_width=31.6u c_length=31.6u
X320 ESD_RAIL a_43813_117064# a_44789_117064# ESD_RAIL pfet_06v0 ad=1.3p pd=5.52u as=1.3p ps=5.52u w=5u l=0.7u
X321 ESD_RAIL a_41852_148519# VSS VSS nfet_06v0 ad=13.936p pd=54.12u as=13.936p ps=54.12u w=53.6u l=0.7u
X322 VDD FS_P_GATE FS_P_WELL FS_P_WELL pfet_03v3 ad=6.16p pd=28.88u as=6.16p ps=28.88u w=14u l=0.28u
X323 VSS a_41852_148519# ESD_RAIL VSS nfet_06v0 ad=13.936p pd=54.12u as=13.936p ps=54.12u w=53.6u l=0.7u
X324 PULLUP_N_OUT PAD_N VSS ppolyf_u_1k r_width=1u r_length=1.18u
X325 VSS a_41852_148519# ESD_RAIL VSS nfet_06v0 ad=13.936p pd=54.12u as=13.936p ps=54.12u w=53.6u l=0.7u
X326 VSS a_41852_148519# ESD_RAIL VSS nfet_06v0 ad=13.936p pd=54.12u as=13.936p ps=54.12u w=53.6u l=0.7u
X327 VDD FS_P_GATE FS_P_WELL FS_P_WELL pfet_03v3 ad=6.16p pd=28.88u as=6.16p ps=28.88u w=14u l=0.28u
X328 VSS a_41852_148519# ESD_RAIL VSS nfet_06v0 ad=13.936p pd=54.12u as=13.936p ps=54.12u w=53.6u l=0.7u
X329 FS_N_WELL FS_N_BLEED_0 VSS ppolyf_u_1k r_width=1u r_length=12.5u
D13 VSS PAD_N diode_nd2ps_06v0 pj=51.8u area=22.5p
X330 a_42245_90628# a_44789_117064# ESD_RAIL ESD_RAIL pfet_06v0 ad=1.3p pd=5.52u as=1.3p ps=5.52u w=5u l=0.7u
X331 PULLUP_N_GATE VDD PULLUP_N_WELL PULLUP_N_WELL pfet_03v3 ad=1.76p pd=8.88u as=1.76p ps=8.88u w=4u l=0.28u
X332 VSS a_41852_148519# ESD_RAIL VSS nfet_06v0 ad=13.936p pd=54.12u as=13.936p ps=54.12u w=53.6u l=0.7u
X333 FS_N_OUT FS_N_GATE FS_N_WELL FS_N_WELL pfet_03v3 ad=6.16p pd=28.88u as=6.16p ps=28.88u w=14u l=0.28u
X334 PULLUP_P_WELL PULLUP_P_BLEED_0 VSS ppolyf_u_1k r_width=1u r_length=12.5u
X335 VSS a_41852_148519# ESD_RAIL VSS nfet_06v0 ad=13.936p pd=54.12u as=13.936p ps=54.12u w=53.6u l=0.7u
X336 HS_P_6 HS_PBIAS VDD VDD pfet_03v3 ad=8.8p pd=40.88u as=8.8p ps=40.88u w=20u l=1u
X337 ESD_RAIL a_41852_148519# VSS VSS nfet_06v0 ad=13.936p pd=54.12u as=13.936p ps=54.12u w=53.6u l=0.7u
X338 a_43813_117064# a_41005_131545# ESD_RAIL ESD_RAIL pfet_06v0 ad=1.3p pd=5.52u as=2.2p ps=10.88u w=5u l=0.7u
X339 VSS a_41852_148519# ESD_RAIL VSS nfet_06v0 ad=13.936p pd=54.12u as=13.936p ps=54.12u w=53.6u l=0.7u
X340 ESD_RAIL a_42245_90628# VSS VSS nfet_06v0 ad=22p pd=0.10088m as=13p ps=50.52u w=50u l=0.7u
X341 VSS a_41852_148519# ESD_RAIL VSS nfet_06v0 ad=13.936p pd=54.12u as=13.936p ps=54.12u w=53.6u l=0.7u
X342 VDD FS_N_GATE FS_N_WELL FS_N_WELL pfet_03v3 ad=6.16p pd=28.88u as=6.16p ps=28.88u w=14u l=0.28u
X343 ESD_RAIL a_41852_148519# VSS VSS nfet_06v0 ad=13.936p pd=54.12u as=13.936p ps=54.12u w=53.6u l=0.7u
X344 ESD_RAIL a_42245_90628# VSS VSS nfet_06v0 ad=13p pd=50.52u as=13p ps=50.52u w=50u l=0.7u
X345 VSS a_42245_90628# ESD_RAIL VSS nfet_06v0 ad=13p pd=50.52u as=13p ps=50.52u w=50u l=0.7u
X346 VDD FS_N_GATE FS_N_WELL FS_N_WELL pfet_03v3 ad=6.16p pd=28.88u as=6.16p ps=28.88u w=14u l=0.28u
X347 VDD FS_P_GATE FS_P_WELL FS_P_WELL pfet_03v3 ad=6.16p pd=28.88u as=6.16p ps=28.88u w=14u l=0.28u
X348 VSS a_42245_90628# ESD_RAIL VSS nfet_06v0 ad=13p pd=50.52u as=13p ps=50.52u w=50u l=0.7u
X349 a_44789_117064# a_43813_117064# ESD_RAIL ESD_RAIL pfet_06v0 ad=1.3p pd=5.52u as=1.3p ps=5.52u w=5u l=0.7u
X350 ESD_RAIL a_41852_148519# VSS VSS nfet_06v0 ad=13.936p pd=54.12u as=13.936p ps=54.12u w=53.6u l=0.7u
X351 VDD FS_P_GATE FS_P_WELL FS_P_WELL pfet_03v3 ad=6.16p pd=28.88u as=6.16p ps=28.88u w=14u l=0.28u
X352 HS_P_12 HS_PBIAS VDD VDD pfet_03v3 ad=8.8p pd=40.88u as=8.8p ps=40.88u w=20u l=1u
X353 ESD_RAIL a_41852_148519# VSS VSS nfet_06v0 ad=13.936p pd=54.12u as=13.936p ps=54.12u w=53.6u l=0.7u
X354 ESD_RAIL a_41852_148519# VSS VSS nfet_06v0 ad=13.936p pd=54.12u as=13.936p ps=54.12u w=53.6u l=0.7u
X355 ESD_RAIL a_41852_148519# VSS VSS nfet_06v0 ad=13.936p pd=54.12u as=23.584p ps=0.10808m w=53.6u l=0.7u
X356 TERM_P_R DIFF_ENABLE TERM_N_R VSS nfet_03v3 ad=8.8p pd=40.88u as=8.8p ps=40.88u w=20u l=0.28u
X357 ESD_RAIL a_41852_148519# VSS VSS nfet_06v0 ad=13.936p pd=54.12u as=13.936p ps=54.12u w=53.6u l=0.7u
X358 VSS a_41852_148519# ESD_RAIL VSS nfet_06v0 ad=13.936p pd=54.12u as=13.936p ps=54.12u w=53.6u l=0.7u
X359 TERM_GATE_N_BLEED_0 TERM_GATE_N_BLEED_1 VSS ppolyf_u_1k r_width=1u r_length=12.5u
X360 VSS a_41852_148519# ESD_RAIL VSS nfet_06v0 ad=13.936p pd=54.12u as=13.936p ps=54.12u w=53.6u l=0.7u
X361 PULLUP_P_BLEED_3 PULLUP_P_BLEED_4 VSS ppolyf_u_1k r_width=1u r_length=12.5u
X362 ESD_RAIL a_41852_148519# VSS VSS nfet_06v0 ad=13.936p pd=54.12u as=13.936p ps=54.12u w=53.6u l=0.7u
X363 VDD FS_N_GATE FS_N_WELL FS_N_WELL pfet_03v3 ad=6.16p pd=28.88u as=6.16p ps=28.88u w=14u l=0.28u
X364 VDD FS_P_GATE FS_P_WELL FS_P_WELL pfet_03v3 ad=6.16p pd=28.88u as=6.16p ps=28.88u w=14u l=0.28u
X365 VSS a_41852_148519# ESD_RAIL VSS nfet_06v0 ad=13.936p pd=54.12u as=13.936p ps=54.12u w=53.6u l=0.7u
D14 VSS FS_LOW_N diode_nd2ps_03v3 pj=4.92u area=1.5129p
X366 VDD FS_N_GATE FS_N_WELL FS_N_WELL pfet_03v3 ad=6.16p pd=28.88u as=6.16p ps=28.88u w=14u l=0.28u
X367 TERM_GATE_P TERM_OR_P_B VSS VSS nfet_03v3 ad=1.76p pd=8.88u as=1.76p ps=8.88u w=4u l=0.28u
X368 HS_N_12 HS_PBIAS VDD VDD pfet_03v3 ad=8.8p pd=40.88u as=8.8p ps=40.88u w=20u l=1u
X369 VSS a_42245_90628# ESD_RAIL VSS nfet_06v0 ad=13p pd=50.52u as=22p ps=0.10088m w=50u l=0.7u
X370 ESD_RAIL a_44789_117064# a_42245_90628# ESD_RAIL pfet_06v0 ad=1.3p pd=5.52u as=1.3p ps=5.52u w=5u l=0.7u
X371 HS_N_8 HS_N PAD_N VSS nfet_06v0 ad=8.8p pd=40.88u as=8.8p ps=40.88u w=20u l=0.7u
X372 VSS a_42245_90628# ESD_RAIL VSS nfet_06v0 ad=13p pd=50.52u as=13p ps=50.52u w=50u l=0.7u
X373 PULLUP_N_BLEED_4 PULLUP_N_BLEED_5 VSS ppolyf_u_1k r_width=1u r_length=12.5u
X374 ESD_RAIL a_41852_148519# VSS VSS nfet_06v0 ad=13.936p pd=54.12u as=13.936p ps=54.12u w=53.6u l=0.7u
X375 VSS a_42245_90628# ESD_RAIL VSS nfet_06v0 ad=13p pd=50.52u as=13p ps=50.52u w=50u l=0.7u
X376 ESD_RAIL a_41852_148519# VSS VSS nfet_06v0 ad=13.936p pd=54.12u as=13.936p ps=54.12u w=53.6u l=0.7u
X377 VSS a_41852_148519# ESD_RAIL VSS nfet_06v0 ad=13.936p pd=54.12u as=13.936p ps=54.12u w=53.6u l=0.7u
X378 TERM_OR_P_B FS_LOW_P TERM_OR_P_S VDD pfet_03v3 ad=1.76p pd=8.88u as=1.76p ps=8.88u w=4u l=0.28u
X379 VSS a_41852_148519# ESD_RAIL VSS nfet_06v0 ad=13.936p pd=54.12u as=13.936p ps=54.12u w=53.6u l=0.7u
X380 VDD FS_N_GATE FS_N_WELL FS_N_WELL pfet_03v3 ad=6.16p pd=28.88u as=6.16p ps=28.88u w=14u l=0.28u
X381 ESD_RAIL a_41852_148519# VSS VSS nfet_06v0 ad=13.936p pd=54.12u as=13.936p ps=54.12u w=53.6u l=0.7u
X382 ESD_RAIL a_41852_148519# VSS VSS nfet_06v0 ad=13.936p pd=54.12u as=13.936p ps=54.12u w=53.6u l=0.7u
X383 VSS a_41852_148519# ESD_RAIL VSS nfet_06v0 ad=13.936p pd=54.12u as=13.936p ps=54.12u w=53.6u l=0.7u
X384 TERM_GATE_P TERM_OR_P_B VDD VDD pfet_03v3 ad=3.52p pd=16.88u as=3.52p ps=16.88u w=8u l=0.28u
X385 VSS RX_N VSS ppolyf_u_1k_6p0 r_width=1u r_length=0.31954m
X386 HS_N_10 HS_PBIAS VDD VDD pfet_03v3 ad=8.8p pd=40.88u as=8.8p ps=40.88u w=20u l=1u
X387 ESD_RAIL a_41852_148519# VSS VSS nfet_06v0 ad=13.936p pd=54.12u as=13.936p ps=54.12u w=53.6u l=0.7u
D15 PAD_P ESD_RAIL diode_pd2nw_06v0 pj=51.8u area=22.5p
X388 TERM_OR_P_B FS_LOW_P TERM_OR_P_NS VSS nfet_03v3 ad=0.88p pd=4.88u as=0.88p ps=4.88u w=2u l=0.28u
X389 FS_N_BLEED_3 FS_N_BLEED_4 VSS ppolyf_u_1k r_width=1u r_length=12.5u
X390 ESD_RAIL a_42245_90628# VSS VSS nfet_06v0 ad=13p pd=50.52u as=13p ps=50.52u w=50u l=0.7u
X391 VSS a_41852_148519# ESD_RAIL VSS nfet_06v0 ad=13.936p pd=54.12u as=13.936p ps=54.12u w=53.6u l=0.7u
X392 PULLUP_N_BLEED_0 PULLUP_N_BLEED_1 VSS ppolyf_u_1k r_width=1u r_length=12.5u
D16 VSS FS_LOW_P diode_nd2ps_03v3 pj=8.76u area=4.7961p
X393 FS_P_BLEED_4 FS_P_BLEED_5 VSS ppolyf_u_1k r_width=1u r_length=12.5u
X394 VSS a_42245_90628# ESD_RAIL VSS nfet_06v0 ad=13p pd=50.52u as=13p ps=50.52u w=50u l=0.7u
X395 VSS a_41852_148519# ESD_RAIL VSS nfet_06v0 ad=23.584p pd=0.10808m as=13.936p ps=54.12u w=53.6u l=0.7u
X396 FS_P_OUT FS_P_GATE FS_P_WELL FS_P_WELL pfet_03v3 ad=6.16p pd=28.88u as=6.16p ps=28.88u w=14u l=0.28u
X397 VSS a_41852_148519# ESD_RAIL VSS nfet_06v0 ad=13.936p pd=54.12u as=13.936p ps=54.12u w=53.6u l=0.7u
X398 VSS a_43813_117064# a_44789_117064# VSS nfet_06v0 ad=1.3p pd=5.52u as=1.3p ps=5.52u w=5u l=0.7u
X399 VDD PULLUP_P_GATE PULLUP_P_WELL PULLUP_P_WELL pfet_03v3 ad=8.8p pd=40.88u as=8.8p ps=40.88u w=20u l=0.28u
X400 FS_N_BLEED_5 FS_N_BLEED_6 VSS ppolyf_u_1k r_width=1u r_length=12.5u
X401 ESD_RAIL a_41852_148519# VSS VSS nfet_06v0 ad=13.936p pd=54.12u as=13.936p ps=54.12u w=53.6u l=0.7u
X402 VDD FS_N_GATE FS_N_WELL FS_N_WELL pfet_03v3 ad=6.16p pd=28.88u as=6.16p ps=28.88u w=14u l=0.28u
X403 ESD_RAIL a_41852_148519# VSS VSS nfet_06v0 ad=13.936p pd=54.12u as=13.936p ps=54.12u w=53.6u l=0.7u
X404 ESD_RAIL a_42245_90628# VSS VSS nfet_06v0 ad=22p pd=0.10088m as=13p ps=50.52u w=50u l=0.7u
X405 HS_N_1 HS_N PAD_N VSS nfet_06v0 ad=8.8p pd=40.88u as=8.8p ps=40.88u w=20u l=0.7u
X406 VSS a_41852_148519# ESD_RAIL VSS nfet_06v0 ad=13.936p pd=54.12u as=13.936p ps=54.12u w=53.6u l=0.7u
X407 VSS a_42245_90628# ESD_RAIL VSS nfet_06v0 ad=13p pd=50.52u as=13p ps=50.52u w=50u l=0.7u
X408 ESD_RAIL a_41852_148519# VSS VSS nfet_06v0 ad=13.936p pd=54.12u as=23.584p ps=0.10808m w=53.6u l=0.7u
X409 HS_N_4 HS_PBIAS VDD VDD pfet_03v3 ad=8.8p pd=40.88u as=8.8p ps=40.88u w=20u l=1u
D17 VSS PAD_P diode_nd2ps_06v0 pj=51.8u area=22.5p
X410 FS_N_GATE FS_HIGH_N FS_N_CONTROL_S VSS nfet_06v0 ad=0.88p pd=4.88u as=0.88p ps=4.88u w=2u l=0.7u
X411 VSS a_44789_117064# a_42245_90628# VSS nfet_06v0 ad=1.3p pd=5.52u as=1.3p ps=5.52u w=5u l=0.7u
X412 ESD_RAIL a_41852_148519# VSS VSS nfet_06v0 ad=13.936p pd=54.12u as=13.936p ps=54.12u w=53.6u l=0.7u
X413 VDD FS_N_GATE FS_N_WELL FS_N_WELL pfet_03v3 ad=6.16p pd=28.88u as=6.16p ps=28.88u w=14u l=0.28u
X414 ESD_RAIL a_41852_148519# VSS VSS nfet_06v0 ad=13.936p pd=54.12u as=13.936p ps=54.12u w=53.6u l=0.7u
X415 VSS a_44789_117064# a_42245_90628# VSS nfet_06v0 ad=1.3p pd=5.52u as=1.3p ps=5.52u w=5u l=0.7u
X416 TERM_GATE_N TERM_OR_N_B VSS VSS nfet_03v3 ad=1.76p pd=8.88u as=1.76p ps=8.88u w=4u l=0.28u
X417 VSS a_41852_148519# ESD_RAIL VSS nfet_06v0 ad=13.936p pd=54.12u as=13.936p ps=54.12u w=53.6u l=0.7u
X418 VSS a_41852_148519# ESD_RAIL VSS nfet_06v0 ad=13.936p pd=54.12u as=13.936p ps=54.12u w=53.6u l=0.7u
X419 ESD_RAIL a_44789_117064# a_42245_90628# ESD_RAIL pfet_06v0 ad=1.3p pd=5.52u as=1.3p ps=5.52u w=5u l=0.7u
X420 VSS a_41852_148519# ESD_RAIL VSS nfet_06v0 ad=23.584p pd=0.10808m as=13.936p ps=54.12u w=53.6u l=0.7u
X421 ESD_RAIL a_41852_148519# cap_mim_2f0_m4m5_noshield c_width=90u c_length=90u
X422 ESD_RAIL a_41852_148519# VSS VSS nfet_06v0 ad=13.936p pd=54.12u as=13.936p ps=54.12u w=53.6u l=0.7u
X423 a_41005_131545# a_53878_131545# ESD_RAIL ppolyf_u r_width=0.8u r_length=63.855u
X424 VSS a_42245_90628# ESD_RAIL VSS nfet_06v0 ad=13p pd=50.52u as=13p ps=50.52u w=50u l=0.7u
X425 HS_N_10 HS_N PAD_N VSS nfet_06v0 ad=8.8p pd=40.88u as=8.8p ps=40.88u w=20u l=0.7u
X426 PAD_N BYPASS_ENABLE RX_N VSS nfet_06v0 ad=8.8p pd=40.88u as=8.8p ps=40.88u w=20u l=0.7u
X427 TERM_P_R TERM_GATE_P TERM_VCM VSS nfet_03v3 ad=8.8p pd=40.88u as=8.8p ps=40.88u w=20u l=0.28u
X428 VDD FS_N_GATE FS_N_WELL FS_N_WELL pfet_03v3 ad=6.16p pd=28.88u as=6.16p ps=28.88u w=14u l=0.28u
X429 ESD_RAIL a_42245_90628# VSS VSS nfet_06v0 ad=13p pd=50.52u as=13p ps=50.52u w=50u l=0.7u
D18 PAD_N ESD_RAIL diode_pd2nw_06v0 pj=51.8u area=22.5p
X430 a_44789_117064# a_43813_117064# VSS VSS nfet_06v0 ad=1.3p pd=5.52u as=1.3p ps=5.52u w=5u l=0.7u
X431 ESD_RAIL a_42245_90628# VSS VSS nfet_06v0 ad=13p pd=50.52u as=13p ps=50.52u w=50u l=0.7u
X432 HS_N_3 HS_N PAD_N VSS nfet_06v0 ad=8.8p pd=40.88u as=8.8p ps=40.88u w=20u l=0.7u
X433 VDD FS_N_GATE FS_N_WELL FS_N_WELL pfet_03v3 ad=6.16p pd=28.88u as=6.16p ps=28.88u w=14u l=0.28u
X434 ESD_RAIL a_41852_148519# VSS VSS nfet_06v0 ad=13.936p pd=54.12u as=13.936p ps=54.12u w=53.6u l=0.7u
X435 ESD_RAIL a_41852_148519# VSS VSS nfet_06v0 ad=13.936p pd=54.12u as=13.936p ps=54.12u w=53.6u l=0.7u
X436 PULLUP_N_OUT PULLUP_N_GATE PULLUP_N_WELL PULLUP_N_WELL pfet_03v3 ad=8.8p pd=40.88u as=8.8p ps=40.88u w=20u l=0.28u
X437 VDD FS_N_GATE FS_N_WELL FS_N_WELL pfet_03v3 ad=6.16p pd=28.88u as=6.16p ps=28.88u w=14u l=0.28u
X438 FS_P_OUT FS_P_GATE FS_P_WELL FS_P_WELL pfet_03v3 ad=6.16p pd=28.88u as=6.16p ps=28.88u w=14u l=0.28u
X439 VSS a_42245_90628# ESD_RAIL VSS nfet_06v0 ad=13p pd=50.52u as=13p ps=50.52u w=50u l=0.7u
X440 VSS a_41852_148519# ESD_RAIL VSS nfet_06v0 ad=13.936p pd=54.12u as=13.936p ps=54.12u w=53.6u l=0.7u
X441 VSS a_41852_148519# ESD_RAIL VSS nfet_06v0 ad=13.936p pd=54.12u as=13.936p ps=54.12u w=53.6u l=0.7u
X442 VDD FS_N_GATE FS_N_WELL FS_N_WELL pfet_03v3 ad=6.16p pd=28.88u as=6.16p ps=28.88u w=14u l=0.28u
X443 VSS a_41852_148519# ESD_RAIL VSS nfet_06v0 ad=13.936p pd=54.12u as=13.936p ps=54.12u w=53.6u l=0.7u
X444 ESD_RAIL a_41852_148519# VSS VSS nfet_06v0 ad=13.936p pd=54.12u as=13.936p ps=54.12u w=53.6u l=0.7u
X445 TERM_N_R TERM_GATE_N TERM_VCM VSS nfet_03v3 ad=8.8p pd=40.88u as=8.8p ps=40.88u w=20u l=0.28u
X446 ESD_RAIL a_41852_148519# VSS VSS nfet_06v0 ad=13.936p pd=54.12u as=13.936p ps=54.12u w=53.6u l=0.7u
X447 VDD FS_N_GATE FS_N_WELL FS_N_WELL pfet_03v3 ad=6.16p pd=28.88u as=6.16p ps=28.88u w=14u l=0.28u
X448 a_41005_132385# a_53878_132665# ESD_RAIL ppolyf_u r_width=0.8u r_length=63.855u
X449 VSS a_41852_148519# ESD_RAIL VSS nfet_06v0 ad=13.936p pd=54.12u as=13.936p ps=54.12u w=53.6u l=0.7u
X450 ESD_RAIL a_41852_148519# VSS VSS nfet_06v0 ad=13.936p pd=54.12u as=13.936p ps=54.12u w=53.6u l=0.7u
X451 VSS a_41852_148519# ESD_RAIL VSS nfet_06v0 ad=13.936p pd=54.12u as=13.936p ps=54.12u w=53.6u l=0.7u
X452 TERM_OR_N_B FS_LOW_N TERM_OR_N_S VDD pfet_03v3 ad=1.76p pd=8.88u as=1.76p ps=8.88u w=4u l=0.28u
X453 FS_P_OUT FS_P_GATE FS_P_WELL FS_P_WELL pfet_03v3 ad=6.16p pd=28.88u as=6.16p ps=28.88u w=14u l=0.28u
X454 VSS a_42245_90628# ESD_RAIL VSS nfet_06v0 ad=13p pd=50.52u as=13p ps=50.52u w=50u l=0.7u
X455 HS_N_0 HS_PBIAS VDD VDD pfet_03v3 ad=8.8p pd=40.88u as=8.8p ps=40.88u w=20u l=1u
X456 VSS a_41852_148519# ESD_RAIL VSS nfet_06v0 ad=13.936p pd=54.12u as=13.936p ps=54.12u w=53.6u l=0.7u
X457 PULLUP_P_GATE VDD PULLUP_P_WELL PULLUP_P_WELL pfet_03v3 ad=1.76p pd=8.88u as=1.76p ps=8.88u w=4u l=0.28u
X458 FS_P_OUT FS_P_GATE FS_P_WELL FS_P_WELL pfet_03v3 ad=6.16p pd=28.88u as=6.16p ps=28.88u w=14u l=0.28u
X459 ESD_RAIL a_41852_148519# VSS VSS nfet_06v0 ad=13.936p pd=54.12u as=13.936p ps=54.12u w=53.6u l=0.7u
X460 VSS a_42245_90628# ESD_RAIL VSS nfet_06v0 ad=13p pd=50.52u as=13p ps=50.52u w=50u l=0.7u
X461 ESD_RAIL a_41852_148519# VSS VSS nfet_06v0 ad=13.936p pd=54.12u as=13.936p ps=54.12u w=53.6u l=0.7u
X462 HS_P_1 HS_PBIAS VDD VDD pfet_03v3 ad=8.8p pd=40.88u as=8.8p ps=40.88u w=20u l=1u
X463 PULLUP_P_BLEED_0 PULLUP_P_BLEED_1 VSS ppolyf_u_1k r_width=1u r_length=12.5u
X464 PULLUP_N_CONTROL_S VDD VSS VSS nfet_03v3 ad=1.76p pd=8.88u as=1.76p ps=8.88u w=4u l=0.28u
X465 ESD_RAIL a_42245_90628# VSS VSS nfet_06v0 ad=13p pd=50.52u as=13p ps=50.52u w=50u l=0.7u
X466 ESD_RAIL a_41852_148519# VSS VSS nfet_06v0 ad=13.936p pd=54.12u as=23.584p ps=0.10808m w=53.6u l=0.7u
X467 ESD_RAIL a_41852_148519# VSS VSS nfet_06v0 ad=13.936p pd=54.12u as=13.936p ps=54.12u w=53.6u l=0.7u
X468 VDD FS_N_GATE FS_N_WELL FS_N_WELL pfet_03v3 ad=6.16p pd=28.88u as=6.16p ps=28.88u w=14u l=0.28u
X469 PULLUP_P_BLEED_6 PULLUP_P_GATE VSS ppolyf_u_1k r_width=1u r_length=12.5u
X470 HS_P_0 HS_P PAD_P VSS nfet_06v0 ad=8.8p pd=40.88u as=8.8p ps=40.88u w=20u l=0.7u
X471 VDD FS_N_GATE FS_N_WELL FS_N_WELL pfet_03v3 ad=6.16p pd=28.88u as=6.16p ps=28.88u w=14u l=0.28u
X472 FS_P_OUT FS_P_GATE FS_P_WELL FS_P_WELL pfet_03v3 ad=6.16p pd=28.88u as=6.16p ps=28.88u w=14u l=0.28u
X473 ESD_RAIL a_41852_148519# VSS VSS nfet_06v0 ad=13.936p pd=54.12u as=13.936p ps=54.12u w=53.6u l=0.7u
D19 PAD_N ESD_RAIL diode_pd2nw_06v0 pj=51.8u area=22.5p
X474 PAD_P BYPASS_ENABLE RX_P VSS nfet_06v0 ad=8.8p pd=40.88u as=8.8p ps=40.88u w=20u l=0.7u
X475 VDD FS_N_GATE FS_N_WELL FS_N_WELL pfet_03v3 ad=6.16p pd=28.88u as=6.16p ps=28.88u w=14u l=0.28u
X476 FS_P_OUT FS_P_GATE FS_P_WELL FS_P_WELL pfet_03v3 ad=6.16p pd=28.88u as=6.16p ps=28.88u w=14u l=0.28u
X477 VSS a_41852_148519# ESD_RAIL VSS nfet_06v0 ad=13.936p pd=54.12u as=13.936p ps=54.12u w=53.6u l=0.7u
X478 a_41005_133505# a_53878_133785# ESD_RAIL ppolyf_u r_width=0.8u r_length=63.855u
X479 VSS a_41852_148519# ESD_RAIL VSS nfet_06v0 ad=13.936p pd=54.12u as=13.936p ps=54.12u w=53.6u l=0.7u
X480 VDD PULLUP_P_GATE PULLUP_P_WELL PULLUP_P_WELL pfet_03v3 ad=8.8p pd=40.88u as=8.8p ps=40.88u w=20u l=0.28u
X481 ESD_RAIL a_41852_148519# VSS VSS nfet_06v0 ad=13.936p pd=54.12u as=13.936p ps=54.12u w=53.6u l=0.7u
X482 ESD_RAIL a_42245_90628# VSS VSS nfet_06v0 ad=13p pd=50.52u as=13p ps=50.52u w=50u l=0.7u
X483 PAD_P BYPASS_ENABLE RX_P VSS nfet_06v0 ad=8.8p pd=40.88u as=8.8p ps=40.88u w=20u l=0.7u
X484 VDD FS_N_GATE FS_N_WELL FS_N_WELL pfet_03v3 ad=6.16p pd=28.88u as=6.16p ps=28.88u w=14u l=0.28u
X485 ESD_RAIL a_42245_90628# VSS VSS nfet_06v0 ad=13p pd=50.52u as=13p ps=50.52u w=50u l=0.7u
X486 VSS a_42245_90628# ESD_RAIL VSS nfet_06v0 ad=13p pd=50.52u as=13p ps=50.52u w=50u l=0.7u
X487 HS_P_5 HS_PBIAS VDD VDD pfet_03v3 ad=8.8p pd=40.88u as=8.8p ps=40.88u w=20u l=1u
X488 VSS a_41852_148519# ESD_RAIL VSS nfet_06v0 ad=13.936p pd=54.12u as=13.936p ps=54.12u w=53.6u l=0.7u
X489 ESD_RAIL a_44789_117064# a_42245_90628# ESD_RAIL pfet_06v0 ad=1.3p pd=5.52u as=1.3p ps=5.52u w=5u l=0.7u
X490 VSS a_41852_148519# ESD_RAIL VSS nfet_06v0 ad=13.936p pd=54.12u as=13.936p ps=54.12u w=53.6u l=0.7u
X491 VSS a_41852_148519# ESD_RAIL VSS nfet_06v0 ad=13.936p pd=54.12u as=13.936p ps=54.12u w=53.6u l=0.7u
D20 VSS PULLDOWN_P diode_nd2ps_03v3 pj=4.92u area=1.5129p
X492 VSS a_42245_90628# ESD_RAIL VSS nfet_06v0 ad=13p pd=50.52u as=13p ps=50.52u w=50u l=0.7u
X493 ESD_RAIL a_41852_148519# VSS VSS nfet_06v0 ad=13.936p pd=54.12u as=13.936p ps=54.12u w=53.6u l=0.7u
X494 FS_P_OUT FS_P_GATE FS_P_WELL FS_P_WELL pfet_03v3 ad=6.16p pd=28.88u as=6.16p ps=28.88u w=14u l=0.28u
X495 VSS a_41852_148519# ESD_RAIL VSS nfet_06v0 ad=13.936p pd=54.12u as=13.936p ps=54.12u w=53.6u l=0.7u
X496 HS_P_8 HS_P PAD_P VSS nfet_06v0 ad=8.8p pd=40.88u as=8.8p ps=40.88u w=20u l=0.7u
X497 a_44789_117064# a_43813_117064# VSS VSS nfet_06v0 ad=1.3p pd=5.52u as=1.3p ps=5.52u w=5u l=0.7u
X498 FS_P_OUT FS_P_GATE FS_P_WELL FS_P_WELL pfet_03v3 ad=6.16p pd=28.88u as=6.16p ps=28.88u w=14u l=0.28u
X499 VSS a_41852_148519# ESD_RAIL VSS nfet_06v0 ad=13.936p pd=54.12u as=13.936p ps=54.12u w=53.6u l=0.7u
X500 ESD_RAIL a_41852_148519# VSS VSS nfet_06v0 ad=13.936p pd=54.12u as=23.584p ps=0.10808m w=53.6u l=0.7u
X501 ESD_RAIL a_41852_148519# VSS VSS nfet_06v0 ad=13.936p pd=54.12u as=23.584p ps=0.10808m w=53.6u l=0.7u
X502 ESD_RAIL a_41852_148519# VSS VSS nfet_06v0 ad=13.936p pd=54.12u as=13.936p ps=54.12u w=53.6u l=0.7u
D21 VSS ESD_RAIL diode_nd2ps_06v0 pj=82u area=40p
X503 VSS a_41852_148519# ESD_RAIL VSS nfet_06v0 ad=13.936p pd=54.12u as=13.936p ps=54.12u w=53.6u l=0.7u
X504 VSS a_41852_148519# ESD_RAIL VSS nfet_06v0 ad=23.584p pd=0.10808m as=13.936p ps=54.12u w=53.6u l=0.7u
X505 DIV_LOW_N DIV_ENABLE VSS VSS nfet_03v3 ad=8.8p pd=40.88u as=8.8p ps=40.88u w=20u l=0.28u
X506 VSS a_42245_90628# ESD_RAIL VSS nfet_06v0 ad=13p pd=50.52u as=13p ps=50.52u w=50u l=0.7u
X507 VSS a_42245_90628# ESD_RAIL VSS nfet_06v0 ad=13p pd=50.52u as=13p ps=50.52u w=50u l=0.7u
X508 VDD FS_N_GATE FS_N_WELL FS_N_WELL pfet_03v3 ad=6.16p pd=28.88u as=6.16p ps=28.88u w=14u l=0.28u
X509 ESD_RAIL a_41852_148519# VSS VSS nfet_06v0 ad=13.936p pd=54.12u as=13.936p ps=54.12u w=53.6u l=0.7u
X510 VSS a_42245_90628# ESD_RAIL VSS nfet_06v0 ad=13p pd=50.52u as=13p ps=50.52u w=50u l=0.7u
X511 a_42245_90628# VSS VSS ppolyf_u_1k_6p0 r_width=1u r_length=99.24u
X512 VSS a_42245_90628# ESD_RAIL VSS nfet_06v0 ad=13p pd=50.52u as=13p ps=50.52u w=50u l=0.7u
X513 ESD_RAIL a_42245_90628# VSS VSS nfet_06v0 ad=13p pd=50.52u as=13p ps=50.52u w=50u l=0.7u
X514 HS_P_7 HS_P PAD_P VSS nfet_06v0 ad=8.8p pd=40.88u as=8.8p ps=40.88u w=20u l=0.7u
X515 TERM_GATE_P_BLEED_0 TERM_GATE_P_BLEED_1 VSS ppolyf_u_1k r_width=1u r_length=12.5u
X516 ESD_RAIL a_41852_148519# VSS VSS nfet_06v0 ad=13.936p pd=54.12u as=13.936p ps=54.12u w=53.6u l=0.7u
X517 VSS a_41852_148519# ESD_RAIL VSS nfet_06v0 ad=13.936p pd=54.12u as=13.936p ps=54.12u w=53.6u l=0.7u
X518 ESD_RAIL a_42245_90628# VSS VSS nfet_06v0 ad=22p pd=0.10088m as=13p ps=50.52u w=50u l=0.7u
X519 a_41005_133505# a_53878_133225# ESD_RAIL ppolyf_u r_width=0.8u r_length=63.855u
X520 ESD_RAIL a_41852_148519# VSS VSS nfet_06v0 ad=13.936p pd=54.12u as=13.936p ps=54.12u w=53.6u l=0.7u
X521 FS_P_BLEED_5 FS_P_BLEED_6 VSS ppolyf_u_1k r_width=1u r_length=12.5u
X522 PULLUP_P_OUT PULLUP_P_GATE PULLUP_P_WELL PULLUP_P_WELL pfet_03v3 ad=8.8p pd=40.88u as=8.8p ps=40.88u w=20u l=0.28u
X523 VDD FS_P_GATE FS_P_WELL FS_P_WELL pfet_03v3 ad=6.16p pd=28.88u as=6.16p ps=28.88u w=14u l=0.28u
X524 DIV_P DIV_LOW_P VSS ppolyf_u_1k r_width=1u r_length=2u
X525 VSS a_41852_148519# ESD_RAIL VSS nfet_06v0 ad=23.584p pd=0.10808m as=13.936p ps=54.12u w=53.6u l=0.7u
X526 TERM_N_R TERM_GATE_N TERM_VCM VSS nfet_03v3 ad=8.8p pd=40.88u as=8.8p ps=40.88u w=20u l=0.28u
X527 HS_P_1 HS_P PAD_P VSS nfet_06v0 ad=8.8p pd=40.88u as=8.8p ps=40.88u w=20u l=0.7u
X528 TERM_P_R TERM_GATE_P TERM_VCM VSS nfet_03v3 ad=8.8p pd=40.88u as=8.8p ps=40.88u w=20u l=0.28u
X529 HS_N_5 HS_PBIAS VDD VDD pfet_03v3 ad=8.8p pd=40.88u as=8.8p ps=40.88u w=20u l=1u
X530 PAD_P TERM_P_R VSS ppolyf_u r_width=16u r_length=1.3u
X531 TERM_N_R TERM_GATE_N TERM_VCM VSS nfet_03v3 ad=8.8p pd=40.88u as=8.8p ps=40.88u w=20u l=0.28u
X532 HS_P_4 HS_P PAD_P VSS nfet_06v0 ad=8.8p pd=40.88u as=8.8p ps=40.88u w=20u l=0.7u
X533 VSS a_41852_148519# ESD_RAIL VSS nfet_06v0 ad=13.936p pd=54.12u as=13.936p ps=54.12u w=53.6u l=0.7u
X534 VSS a_42245_90628# ESD_RAIL VSS nfet_06v0 ad=13p pd=50.52u as=13p ps=50.52u w=50u l=0.7u
X535 FS_P_GATE VDD FS_P_WELL FS_P_WELL pfet_03v3 ad=1.76p pd=8.88u as=1.76p ps=8.88u w=4u l=0.28u
X536 FS_N_BLEED_2 FS_N_BLEED_3 VSS ppolyf_u_1k r_width=1u r_length=12.5u
X537 ESD_RAIL a_41852_148519# VSS VSS nfet_06v0 ad=13.936p pd=54.12u as=13.936p ps=54.12u w=53.6u l=0.7u
X538 ESD_RAIL a_41852_148519# VSS VSS nfet_06v0 ad=13.936p pd=54.12u as=13.936p ps=54.12u w=53.6u l=0.7u
X539 FS_N_GATE FS_HIGH_N FS_N_WELL FS_N_WELL pfet_03v3 ad=1.76p pd=8.88u as=1.76p ps=8.88u w=4u l=0.28u
X540 DIV_N DIV_LOW_N VSS ppolyf_u_1k r_width=1u r_length=2u
X541 TERM_GATE_N TERM_GATE_N_BLEED_0 VSS ppolyf_u_1k r_width=1u r_length=12.5u
X542 ESD_RAIL a_44789_117064# a_42245_90628# ESD_RAIL pfet_06v0 ad=1.3p pd=5.52u as=1.3p ps=5.52u w=5u l=0.7u
X543 PULLUP_N_WELL PULLUP_N_BLEED_0 VSS ppolyf_u_1k r_width=1u r_length=12.5u
X544 FS_P_BLEED_3 FS_P_BLEED_4 VSS ppolyf_u_1k r_width=1u r_length=12.5u
X545 VSS a_41852_148519# ESD_RAIL VSS nfet_06v0 ad=13.936p pd=54.12u as=13.936p ps=54.12u w=53.6u l=0.7u
X546 ESD_RAIL a_42245_90628# VSS VSS nfet_06v0 ad=13p pd=50.52u as=13p ps=50.52u w=50u l=0.7u
X547 PULLUP_P_BLEED_2 PULLUP_P_BLEED_3 VSS ppolyf_u_1k r_width=1u r_length=12.5u
X548 PULLUP_P_OUT PULLUP_P_GATE PULLUP_P_WELL PULLUP_P_WELL pfet_03v3 ad=8.8p pd=40.88u as=8.8p ps=40.88u w=20u l=0.28u
X549 VDD FS_P_GATE FS_P_WELL FS_P_WELL pfet_03v3 ad=6.16p pd=28.88u as=6.16p ps=28.88u w=14u l=0.28u
X550 ESD_RAIL a_53878_134345# ESD_RAIL ppolyf_u r_width=0.8u r_length=63.855u
X551 FS_N_BLEED_4 FS_N_BLEED_5 VSS ppolyf_u_1k r_width=1u r_length=12.5u
X552 ESD_RAIL a_41852_148519# VSS VSS nfet_06v0 ad=13.936p pd=54.12u as=13.936p ps=54.12u w=53.6u l=0.7u
D22 VSS PAD_N diode_nd2ps_06v0 pj=51.8u area=22.5p
D23 PAD_P ESD_RAIL diode_pd2nw_06v0 pj=51.8u area=22.5p
X553 HS_P_13 HS_P PAD_P VSS nfet_06v0 ad=8.8p pd=40.88u as=8.8p ps=40.88u w=20u l=0.7u
X554 ESD_RAIL a_41852_148519# VSS VSS nfet_06v0 ad=13.936p pd=54.12u as=13.936p ps=54.12u w=53.6u l=0.7u
X555 ESD_RAIL a_41852_148519# VSS VSS nfet_06v0 ad=13.936p pd=54.12u as=13.936p ps=54.12u w=53.6u l=0.7u
X556 ESD_RAIL a_41852_148519# VSS VSS nfet_06v0 ad=13.936p pd=54.12u as=13.936p ps=54.12u w=53.6u l=0.7u
X557 VDD PULLUP_N_GATE PULLUP_N_WELL PULLUP_N_WELL pfet_03v3 ad=8.8p pd=40.88u as=8.8p ps=40.88u w=20u l=0.28u
X558 HS_N_3 HS_PBIAS VDD VDD pfet_03v3 ad=8.8p pd=40.88u as=8.8p ps=40.88u w=20u l=1u
X559 VSS a_41852_148519# ESD_RAIL VSS nfet_06v0 ad=13.936p pd=54.12u as=13.936p ps=54.12u w=53.6u l=0.7u
X560 ESD_RAIL a_41852_148519# VSS VSS nfet_06v0 ad=13.936p pd=54.12u as=13.936p ps=54.12u w=53.6u l=0.7u
X561 VDD FS_P_GATE FS_P_WELL FS_P_WELL pfet_03v3 ad=6.16p pd=28.88u as=6.16p ps=28.88u w=14u l=0.28u
X562 VSS a_41852_148519# ESD_RAIL VSS nfet_06v0 ad=13.936p pd=54.12u as=13.936p ps=54.12u w=53.6u l=0.7u
X563 VSS a_42245_90628# ESD_RAIL VSS nfet_06v0 ad=13p pd=50.52u as=22p ps=0.10088m w=50u l=0.7u
X564 VSS a_41852_148519# ESD_RAIL VSS nfet_06v0 ad=23.584p pd=0.10808m as=13.936p ps=54.12u w=53.6u l=0.7u
X565 VDD FS_P_GATE FS_P_WELL FS_P_WELL pfet_03v3 ad=6.16p pd=28.88u as=6.16p ps=28.88u w=14u l=0.28u
X566 VSS a_41852_148519# ESD_RAIL VSS nfet_06v0 ad=13.936p pd=54.12u as=13.936p ps=54.12u w=53.6u l=0.7u
X567 VSS a_41852_148519# ESD_RAIL VSS nfet_06v0 ad=13.936p pd=54.12u as=13.936p ps=54.12u w=53.6u l=0.7u
X568 VSS a_42245_90628# ESD_RAIL VSS nfet_06v0 ad=13p pd=50.52u as=13p ps=50.52u w=50u l=0.7u
X569 ESD_RAIL a_42245_90628# VSS VSS nfet_06v0 ad=13p pd=50.52u as=13p ps=50.52u w=50u l=0.7u
X570 HS_N_12 HS_N PAD_N VSS nfet_06v0 ad=8.8p pd=40.88u as=8.8p ps=40.88u w=20u l=0.7u
X571 VSS a_41852_148519# ESD_RAIL VSS nfet_06v0 ad=13.936p pd=54.12u as=13.936p ps=54.12u w=53.6u l=0.7u
X572 ESD_RAIL a_42245_90628# VSS VSS nfet_06v0 ad=13p pd=50.52u as=13p ps=50.52u w=50u l=0.7u
D24 VSS PAD_P diode_nd2ps_06v0 pj=51.8u area=22.5p
X573 PAD_N BYPASS_ENABLE RX_N VSS nfet_06v0 ad=8.8p pd=40.88u as=8.8p ps=40.88u w=20u l=0.7u
X574 ESD_RAIL a_42245_90628# VSS VSS nfet_06v0 ad=13p pd=50.52u as=13p ps=50.52u w=50u l=0.7u
X575 VSS a_41852_148519# ESD_RAIL VSS nfet_06v0 ad=13.936p pd=54.12u as=13.936p ps=54.12u w=53.6u l=0.7u
X576 FS_N_OUT FS_N_GATE FS_N_WELL FS_N_WELL pfet_03v3 ad=6.16p pd=28.88u as=6.16p ps=28.88u w=14u l=0.28u
X577 ESD_RAIL a_41852_148519# VSS VSS nfet_06v0 ad=13.936p pd=54.12u as=13.936p ps=54.12u w=53.6u l=0.7u
X578 VSS a_42245_90628# ESD_RAIL VSS nfet_06v0 ad=13p pd=50.52u as=13p ps=50.52u w=50u l=0.7u
X579 VSS a_41852_148519# ESD_RAIL VSS nfet_06v0 ad=13.936p pd=54.12u as=13.936p ps=54.12u w=53.6u l=0.7u
X580 FS_N_OUT FS_N_GATE FS_N_WELL FS_N_WELL pfet_03v3 ad=6.16p pd=28.88u as=6.16p ps=28.88u w=14u l=0.28u
X581 ESD_RAIL a_41852_148519# VSS VSS nfet_06v0 ad=13.936p pd=54.12u as=13.936p ps=54.12u w=53.6u l=0.7u
X582 HS_P_9 HS_P PAD_P VSS nfet_06v0 ad=8.8p pd=40.88u as=8.8p ps=40.88u w=20u l=0.7u
X583 VDD PULLUP_N_GATE PULLUP_N_WELL PULLUP_N_WELL pfet_03v3 ad=8.8p pd=40.88u as=8.8p ps=40.88u w=20u l=0.28u
X584 FS_N_OUT FS_N_GATE FS_N_WELL FS_N_WELL pfet_03v3 ad=6.16p pd=28.88u as=6.16p ps=28.88u w=14u l=0.28u
X585 VDD FS_P_GATE FS_P_WELL FS_P_WELL pfet_03v3 ad=6.16p pd=28.88u as=6.16p ps=28.88u w=14u l=0.28u
X586 ESD_RAIL a_41852_148519# VSS VSS nfet_06v0 ad=13.936p pd=54.12u as=13.936p ps=54.12u w=53.6u l=0.7u
X587 FS_N_OUT FS_N_GATE FS_N_WELL FS_N_WELL pfet_03v3 ad=6.16p pd=28.88u as=6.16p ps=28.88u w=14u l=0.28u
X588 HS_P_2 HS_PBIAS VDD VDD pfet_03v3 ad=8.8p pd=40.88u as=8.8p ps=40.88u w=20u l=1u
X589 VSS a_41852_148519# ESD_RAIL VSS nfet_06v0 ad=13.936p pd=54.12u as=13.936p ps=54.12u w=53.6u l=0.7u
X590 ESD_RAIL a_41852_148519# VSS VSS nfet_06v0 ad=13.936p pd=54.12u as=13.936p ps=54.12u w=53.6u l=0.7u
X591 ESD_RAIL a_41852_148519# VSS VSS nfet_06v0 ad=13.936p pd=54.12u as=13.936p ps=54.12u w=53.6u l=0.7u
X592 HS_P_8 HS_PBIAS VDD VDD pfet_03v3 ad=8.8p pd=40.88u as=8.8p ps=40.88u w=20u l=1u
X593 ESD_RAIL a_41005_131545# a_43813_117064# ESD_RAIL pfet_06v0 ad=1.3p pd=5.52u as=1.3p ps=5.52u w=5u l=0.7u
X594 VDD FS_P_GATE FS_P_WELL FS_P_WELL pfet_03v3 ad=6.16p pd=28.88u as=6.16p ps=28.88u w=14u l=0.28u
X595 VSS a_41852_148519# ESD_RAIL VSS nfet_06v0 ad=13.936p pd=54.12u as=13.936p ps=54.12u w=53.6u l=0.7u
X596 VDD FS_P_GATE FS_P_WELL FS_P_WELL pfet_03v3 ad=6.16p pd=28.88u as=6.16p ps=28.88u w=14u l=0.28u
X597 FS_N_OUT FS_N_GATE FS_N_WELL FS_N_WELL pfet_03v3 ad=6.16p pd=28.88u as=6.16p ps=28.88u w=14u l=0.28u
X598 HS_N_13 HS_PBIAS VDD VDD pfet_03v3 ad=8.8p pd=40.88u as=8.8p ps=40.88u w=20u l=1u
X599 VDD FS_P_GATE FS_P_WELL FS_P_WELL pfet_03v3 ad=6.16p pd=28.88u as=6.16p ps=28.88u w=14u l=0.28u
X600 PAD_P DIV_P VSS ppolyf_u_1k r_width=1u r_length=2u
X601 PULLDOWN_N_R PULLDOWN_N VSS VSS nfet_03v3 ad=3.52p pd=16.88u as=3.52p ps=16.88u w=8u l=0.28u
X602 FS_P_OUT PAD_P VSS ppolyf_s r_width=2u r_length=3.5u
X603 ESD_RAIL a_41852_148519# VSS VSS nfet_06v0 ad=13.936p pd=54.12u as=13.936p ps=54.12u w=53.6u l=0.7u
X604 VSS a_41852_148519# ESD_RAIL VSS nfet_06v0 ad=13.936p pd=54.12u as=13.936p ps=54.12u w=53.6u l=0.7u
X605 FS_N_OUT FS_N_GATE FS_N_WELL FS_N_WELL pfet_03v3 ad=6.16p pd=28.88u as=6.16p ps=28.88u w=14u l=0.28u
X606 VDD FS_P_GATE FS_P_WELL FS_P_WELL pfet_03v3 ad=6.16p pd=28.88u as=6.16p ps=28.88u w=14u l=0.28u
D25 VSS PAD_N diode_nd2ps_06v0 pj=51.8u area=22.5p
X607 HS_P_0 HS_PBIAS VDD VDD pfet_03v3 ad=8.8p pd=40.88u as=8.8p ps=40.88u w=20u l=1u
X608 VSS a_41852_148519# ESD_RAIL VSS nfet_06v0 ad=13.936p pd=54.12u as=13.936p ps=54.12u w=53.6u l=0.7u
X609 TERM_GATE_N_BLEED_2 VSS VSS ppolyf_u_1k r_width=1u r_length=12.5u
X610 PULLUP_P_OUT PULLUP_P_GATE PULLUP_P_WELL PULLUP_P_WELL pfet_03v3 ad=8.8p pd=40.88u as=8.8p ps=40.88u w=20u l=0.28u
X611 VDD FS_P_GATE FS_P_WELL FS_P_WELL pfet_03v3 ad=6.16p pd=28.88u as=6.16p ps=28.88u w=14u l=0.28u
X612 ESD_RAIL a_41852_148519# VSS VSS nfet_06v0 ad=13.936p pd=54.12u as=13.936p ps=54.12u w=53.6u l=0.7u
D26 VSS PAD_P diode_nd2ps_06v0 pj=51.8u area=22.5p
X613 a_42245_90628# a_44789_117064# ESD_RAIL ESD_RAIL pfet_06v0 ad=1.3p pd=5.52u as=1.3p ps=5.52u w=5u l=0.7u
X614 TERM_P_R TERM_GATE_P TERM_VCM VSS nfet_03v3 ad=8.8p pd=40.88u as=8.8p ps=40.88u w=20u l=0.28u
X615 FS_N_OUT FS_N_GATE FS_N_WELL FS_N_WELL pfet_03v3 ad=6.16p pd=28.88u as=6.16p ps=28.88u w=14u l=0.28u
X616 PULLUP_P_BLEED_5 PULLUP_P_BLEED_6 VSS ppolyf_u_1k r_width=1u r_length=12.5u
X617 TERM_OR_N_B FS_LOW_N TERM_OR_N_NS VSS nfet_03v3 ad=0.88p pd=4.88u as=0.88p ps=4.88u w=2u l=0.28u
X618 HS_P_2 HS_P PAD_P VSS nfet_06v0 ad=8.8p pd=40.88u as=8.8p ps=40.88u w=20u l=0.7u
X619 VDD FS_P_GATE FS_P_WELL FS_P_WELL pfet_03v3 ad=6.16p pd=28.88u as=6.16p ps=28.88u w=14u l=0.28u
X620 VSS a_42245_90628# ESD_RAIL VSS nfet_06v0 ad=13p pd=50.52u as=13p ps=50.52u w=50u l=0.7u
D27 VSS TERM_VCM diode_nd2ps_03v3 pj=2.4u area=0.36p
X621 VSS a_41852_148519# ESD_RAIL VSS nfet_06v0 ad=23.584p pd=0.10808m as=13.936p ps=54.12u w=53.6u l=0.7u
X622 HS_N_7 HS_PBIAS VDD VDD pfet_03v3 ad=8.8p pd=40.88u as=8.8p ps=40.88u w=20u l=1u
X623 FS_N_OUT FS_N_GATE FS_N_WELL FS_N_WELL pfet_03v3 ad=6.16p pd=28.88u as=6.16p ps=28.88u w=14u l=0.28u
X624 VDD FS_P_GATE FS_P_WELL FS_P_WELL pfet_03v3 ad=6.16p pd=28.88u as=6.16p ps=28.88u w=14u l=0.28u
X625 ESD_RAIL a_42245_90628# VSS VSS nfet_06v0 ad=13p pd=50.52u as=13p ps=50.52u w=50u l=0.7u
X626 ESD_RAIL a_42245_90628# VSS VSS nfet_06v0 ad=13p pd=50.52u as=13p ps=50.52u w=50u l=0.7u
X627 VSS a_41852_148519# ESD_RAIL VSS nfet_06v0 ad=13.936p pd=54.12u as=13.936p ps=54.12u w=53.6u l=0.7u
X628 VSS a_41852_148519# ESD_RAIL VSS nfet_06v0 ad=13.936p pd=54.12u as=13.936p ps=54.12u w=53.6u l=0.7u
X629 VSS a_41852_148519# ESD_RAIL VSS nfet_06v0 ad=13.936p pd=54.12u as=13.936p ps=54.12u w=53.6u l=0.7u
X630 HS_N_9 HS_PBIAS VDD VDD pfet_03v3 ad=8.8p pd=40.88u as=8.8p ps=40.88u w=20u l=1u
X631 ESD_RAIL a_42245_90628# VSS VSS nfet_06v0 ad=13p pd=50.52u as=13p ps=50.52u w=50u l=0.7u
X632 VSS a_42245_90628# ESD_RAIL VSS nfet_06v0 ad=13p pd=50.52u as=13p ps=50.52u w=50u l=0.7u
X633 ESD_RAIL a_42245_90628# VSS VSS nfet_06v0 ad=13p pd=50.52u as=13p ps=50.52u w=50u l=0.7u
X634 a_42245_90628# a_44789_117064# ESD_RAIL ESD_RAIL pfet_06v0 ad=1.3p pd=5.52u as=1.3p ps=5.52u w=5u l=0.7u
X635 TERM_OR_P_B TERM_ENABLE VSS VSS nfet_03v3 ad=0.88p pd=4.88u as=0.88p ps=4.88u w=2u l=0.28u
X636 TERM_P_R DIFF_ENABLE TERM_N_R VSS nfet_03v3 ad=8.8p pd=40.88u as=8.8p ps=40.88u w=20u l=0.28u
X637 VSS a_41852_148519# ESD_RAIL VSS nfet_06v0 ad=23.584p pd=0.10808m as=13.936p ps=54.12u w=53.6u l=0.7u
X638 TERM_OR_P_NS VCM_LOW_OK VSS VSS nfet_03v3 ad=1.76p pd=8.88u as=1.76p ps=8.88u w=4u l=0.28u
X639 ESD_RAIL a_41852_148519# VSS VSS nfet_06v0 ad=13.936p pd=54.12u as=13.936p ps=54.12u w=53.6u l=0.7u
X640 FS_N_OUT FS_N_GATE FS_N_WELL FS_N_WELL pfet_03v3 ad=6.16p pd=28.88u as=6.16p ps=28.88u w=14u l=0.28u
X641 TERM_GATE_P_BLEED_1 TERM_GATE_P_BLEED_2 VSS ppolyf_u_1k r_width=1u r_length=12.5u
X642 a_42245_90628# a_44789_117064# ESD_RAIL ESD_RAIL pfet_06v0 ad=1.3p pd=5.52u as=1.3p ps=5.52u w=5u l=0.7u
X643 HS_N_11 HS_N PAD_N VSS nfet_06v0 ad=8.8p pd=40.88u as=8.8p ps=40.88u w=20u l=0.7u
X644 ESD_RAIL a_41852_148519# VSS VSS nfet_06v0 ad=13.936p pd=54.12u as=13.936p ps=54.12u w=53.6u l=0.7u
X645 VSS a_41852_148519# ESD_RAIL VSS nfet_06v0 ad=13.936p pd=54.12u as=13.936p ps=54.12u w=53.6u l=0.7u
X646 HS_N_0 HS_N PAD_N VSS nfet_06v0 ad=8.8p pd=40.88u as=8.8p ps=40.88u w=20u l=0.7u
X647 VDD FS_P_GATE FS_P_WELL FS_P_WELL pfet_03v3 ad=6.16p pd=28.88u as=6.16p ps=28.88u w=14u l=0.28u
X648 VSS a_41852_148519# ESD_RAIL VSS nfet_06v0 ad=13.936p pd=54.12u as=13.936p ps=54.12u w=53.6u l=0.7u
X649 ESD_RAIL a_44789_117064# a_42245_90628# ESD_RAIL pfet_06v0 ad=1.3p pd=5.52u as=1.3p ps=5.52u w=5u l=0.7u
X650 PAD_N BYPASS_ENABLE RX_N VSS nfet_06v0 ad=8.8p pd=40.88u as=8.8p ps=40.88u w=20u l=0.7u
X651 PAD_N BYPASS_ENABLE RX_N VSS nfet_06v0 ad=8.8p pd=40.88u as=8.8p ps=40.88u w=20u l=0.7u
X652 a_41005_132385# a_53878_132105# ESD_RAIL ppolyf_u r_width=0.8u r_length=63.855u
X653 ESD_RAIL a_41852_148519# VSS VSS nfet_06v0 ad=13.936p pd=54.12u as=13.936p ps=54.12u w=53.6u l=0.7u
X654 PULLUP_N_BLEED_2 PULLUP_N_BLEED_3 VSS ppolyf_u_1k r_width=1u r_length=12.5u
X655 ESD_RAIL a_41852_148519# VSS VSS nfet_06v0 ad=13.936p pd=54.12u as=13.936p ps=54.12u w=53.6u l=0.7u
X656 ESD_RAIL a_41852_148519# VSS VSS nfet_06v0 ad=13.936p pd=54.12u as=13.936p ps=54.12u w=53.6u l=0.7u
C0 TERM_ENABLE HS_P_4 0.07923f
C1 PULLUP_N_GATE PULLUP_N_CONTROL_S 1.68347f
C2 PAD_P HS_P_1 1.23389f
C3 HS_N_3 TERM_ENABLE 0.04808f
C4 HS_N_4 VDD 6.4024f
C5 VCM_LOW_OK HS_N_5 0.05893f
C6 FS_P_BLEED_0 HS_N_0 0.06178f
C7 DIV_LOW_N TERM_ENABLE 0.07174f
C8 TERM_OR_N_B HS_P 0
C9 HS_N_7 PULLUP_P_CONTROL_S 0.04808f
C10 FS_P_OUT TERM_GATE_P 0.22814f
C11 HS_N_7 TERM_OR_P_B 0.07211f
C12 HS_P_1 HS_P_9 0.03494f
C13 PULLUP_P_BLEED_3 VDD 0.44664f
C14 PULLUP_P_OUT HS_PBIAS 0.55061f
C15 HS_N HS_N_8 2.66346f
C16 HS_N_2 FS_P_CONTROL_S 0.03226f
C17 FS_N_BLEED_3 FS_N_BLEED_1 0.10633f
C18 TERM_OR_N_NS HS_N_3 0.03425f
C19 FS_P_WELL FS_P_BLEED_0 6.36796f
C20 PULLUP_N_BLEED_0 PULLUP_N 0.85278f
C21 HS_N_4 HS_P_5 0.03511f
C22 HS_P_8 HS_N_8 0.09066f
C23 TERM_VCM TERM_ENABLE 0.55788f
C24 HS_N_10 TERM_ENABLE 0.04862f
C25 HS_N_11 VDD 6.59331f
C26 TERM_ENABLE PULLDOWN_P 0.05932f
C27 PULLUP_N_OUT HS_N_8 0.01067f
C28 PULLUP_N_BLEED_4 PULLUP_N_BLEED_3 1.53214f
C29 FS_N_GATE FS_N_BLEED_2 0.19042f
C30 TERM_OR_P_B HS_P_3 0.10238f
C31 PULLUP_N_GATE PULLDOWN_N 0.00151f
C32 HS_N_6 PULLUP_P_WELL 0.12108f
C33 HS_N_4 TERM_OR_N_S 0.026f
C34 FS_LOW_P HS_N_1 0.21255f
C35 PULLUP_P_BLEED_4 VCM_LOW_OK 0
C36 PULLUP_P_WELL PULLUP_P_BLEED_1 0.15492f
C37 FS_P_OUT RX_N 0.00505f
C38 PULLUP_P_CONTROL_S HS_N_12 0.04885f
C39 HS_N_11 HS_P_5 0.03489f
C40 HS_N_5 HS_P 0.87187f
C41 FS_P_BLEED_6 PULLDOWN_N_R 0.10124f
C42 TERM_OR_N_NS HS_N_10 0.03425f
C43 a_41005_134065# a_41005_133505# 0.0346f
C44 HS_N_0 HS_N_3 0.08089f
C45 HS_N_4 FS_LOW_N 0.08441f
C46 TERM_OR_N_NS TERM_VCM 0.03439f
C47 TERM_OR_N_NS PULLDOWN_P 0.04764f
C48 a_43813_117064# a_42245_90628# 0.00994f
C49 HS_N_12 TERM_OR_P_B 0.07307f
C50 DIV_LOW_N HS_N_0 0.06837f
C51 FS_P_BLEED_0 FS_P_GATE 0.16521f
C52 FS_P_BLEED_3 HS_N_4 0.03227f
C53 PULLUP_P_OUT TERM_P_R 0.25969f
C54 DIV_ENABLE DIV_P 4.76769f
C55 PULLUP_P_BLEED_3 FS_LOW_N 0.00876f
C56 HS_N_11 TERM_OR_N_S 0.02508f
C57 HS_N_4 HS_P_1 0.0586f
C58 TERM_GATE_N_BLEED_2 HS_N 0.05048f
C59 FS_P_WELL HS_N_3 1.96364f
C60 PULLUP_P_BLEED_2 TERM_P_R 0.11063f
C61 HS_P_2 HS_P_0 0.00431f
C62 FS_N_CONTROL_S PULLUP_P 0.10706f
C63 PULLUP_N_BLEED_6 VDD 0.45117f
C64 PULLUP_P PULLDOWN_P_R 0.09196f
C65 HS_N_0 TERM_VCM 0.17286f
C66 TERM_GATE_P_BLEED_1 TERM_GATE_P 0.37616f
C67 TERM_ENABLE HS_N_8 0.04808f
C68 HS_N_0 PULLDOWN_P 0.04428f
C69 HS_N_11 FS_LOW_N 0.08441f
C70 DIV_ENABLE PULLUP_P 0.05123f
C71 HS_N_0 HS_N_10 2.19255f
C72 TERM_OR_P_NS HS_P_10 0.04329f
C73 TERM_GATE_P VDD 7.09843f
C74 PULLUP_P_OUT FS_P_BLEED_4 0.00257f
C75 TERM_VCM FS_N_WELL 1.58767f
C76 HS_N_10 FS_N_WELL 0.00889f
C77 TERM_GATE_N_BLEED_2 PULLUP_N_OUT 0.09196f
C78 DIV_N HS_N_7 0.03462f
C79 PULLUP_N_BLEED_2 PULLUP_N 0.29902f
C80 PULLDOWN_P FS_N_WELL 2.59822f
C81 TERM_GATE_P_BLEED_0 HS_P 0.00154f
C82 FS_P_BLEED_3 HS_N_11 0.029f
C83 DIV_N RX_P 0.72665f
C84 FS_P_WELL TERM_VCM 1.40942f
C85 PULLUP_P DIFF_ENABLE 0.20063f
C86 PULLUP_P_BLEED_4 HS_P 0.0525f
C87 FS_P_BLEED_2 HS_N_1 0
C88 TERM_OR_N_NS HS_N_8 0.03425f
C89 FS_P_OUT FS_P_CONTROL_S 0
C90 FS_P_WELL HS_N_10 2.06442f
C91 HS_N_2 PULLUP_P 0.02404f
C92 TERM_GATE_P HS_P_5 0.15599f
C93 FS_P_GATE HS_N_3 1.03504f
C94 PULLUP_N_GATE PULLUP_N_BLEED_6 6.07282f
C95 HS_P_6 PULLDOWN_N_R 0.02414f
C96 TERM_P_R PULLUP_N 0.07457f
C97 FS_N_BLEED_2 FS_HIGH_P 0
C98 a_53878_133785# a_53878_134345# 0.0346f
C99 HS_N FS_N_BLEED_1 0.11535f
C100 PULLUP_N_BLEED_6 FS_LOW_N 0.06798f
C101 HS_N_0 HS_N_8 0.04157f
C102 DIV_N HS_N_12 0.03462f
C103 HS_N_6 FS_HIGH_P 0.02404f
C104 a_41005_131545# a_42245_90628# 0.01301f
C105 TERM_GATE_N_BLEED_2 TERM_ENABLE 0.07928f
C106 TERM_GATE_N VDD 3.74877f
C107 PULLUP_N_OUT PULLUP_P_BLEED_6 0.09268f
C108 PAD_N HS_P_10 0.42477f
C109 PULLUP_N_OUT FS_N_BLEED_1 0.05216f
C110 FS_N_BLEED_2 PULLDOWN_N_R 0.08856f
C111 FS_P_GATE TERM_VCM 0.64724f
C112 FS_P_GATE HS_N_10 1.04113f
C113 a_53878_134345# ESD_RAIL 0.5677f
C114 PULLUP_P_OUT FS_P_BLEED_1 0.05902f
C115 PAD_P HS_P_6 1.8306f
C116 FS_LOW_P HS_N_5 0.08533f
C117 HS_N_6 PULLDOWN_N_R 0.06832f
C118 PULLUP_N_BLEED_4 PULLUP_N 0.08101f
C119 HS_P_13 HS_P_4 0.14463f
C120 FS_P_WELL HS_N_8 1.99903f
C121 HS_N_13 HS_P_12 0.03621f
C122 TERM_GATE_P HS_P_1 0.25434f
C123 FS_P_BLEED_6 HS_N_4 0.06178f
C124 HS_N_3 HS_P_13 0.02404f
C125 HS_P_9 HS_P_6 0.00106f
C126 PULLUP_P_OUT TERM_OR_P_S 0.00441f
C127 TERM_GATE_N TERM_OR_N_S 0.0189f
C128 FS_P_CONTROL_S VDD 0.38621f
C129 TERM_GATE_N_BLEED_0 FS_HIGH_P 0.15807f
C130 FS_P_OUT DIV_P 0.01279f
C131 TERM_OR_P_NS TERM_OR_P_B 3.40561f
C132 FS_N_BLEED_1 TERM_ENABLE 0.01168f
C133 HS_N_9 FS_P_BLEED_0 0.06178f
C134 HS_N_10 HS_P_13 0.0252f
C135 TERM_ENABLE PULLUP_P_BLEED_6 0
C136 HS_P_13 TERM_VCM 0.09664f
C137 HS_N_6 PAD_P 2.14046f
C138 PULLUP_P_BLEED_5 PULLDOWN_N_R 0.09196f
C139 TERM_GATE_N FS_LOW_N 0.09048f
C140 FS_P_BLEED_6 HS_N_11 0.06178f
C141 TERM_GATE_N_BLEED_2 HS_N_0 0.02492f
C142 FS_P_GATE HS_N_8 1.04761f
C143 a_53878_133785# ESD_RAIL 0.53942f
C144 HS_N_13 HS_N 0.98202f
C145 HS_P_2 PULLDOWN_P_R 0.07466f
C146 TERM_GATE_N_BLEED_0 PULLDOWN_N_R 0.04828f
C147 TERM_N_R VCM_LOW_OK 0.18442f
C148 PULLUP_P_BLEED_4 FS_LOW_P 0.0781f
C149 PULLUP_P_OUT PULLUP_P_GATE 19.8171f
C150 PULLUP_N_WELL DIV_ENABLE 0.06147f
C151 TERM_OR_N_NS PULLUP_P_BLEED_6 0
C152 FS_N_BLEED_3 FS_N_GATE 0.19336f
C153 HS_N_13 PULLUP_N_OUT 0.05062f
C154 PULLUP_P_BLEED_2 PULLUP_P_GATE 0.1764f
C155 FS_P_BLEED_5 HS_PBIAS 0.08856f
C156 HS_N_4 HS_P_6 0.0599f
C157 HS_N_2 HS_P_2 0.06704f
C158 HS_N_9 HS_P_4 0.03089f
C159 HS_P_2 HS_P_11 0.00106f
C160 HS_P_13 HS_N_8 0.04828f
C161 HS_N_9 HS_N_3 0.03256f
C162 HS_N_9 DIV_LOW_N 0.06178f
C163 HS_P_10 HS_PBIAS 8.55407f
C164 HS_N_7 HS_N_12 0.02955f
C165 FS_N_BLEED_1 FS_N_WELL 0.5326f
C166 HS_N_11 HS_P_6 0.05932f
C167 VDD DIV_P 0.11168f
C168 HS_N_13 TERM_ENABLE 0.10332f
C169 TERM_N_R HS_P 0.08926f
C170 HS_N_6 HS_N_4 0.05831f
C171 FS_N_GATE FS_N_BLEED_5 0.25656f
C172 HS_N_9 TERM_VCM 0.14022f
C173 PULLUP_P VDD 2.22026f
C174 HS_N_9 HS_N_10 0.03655f
C175 HS_N_6 PULLUP_P_BLEED_3 0.03489f
C176 HS_N_12 HS_P_3 0.02482f
C177 HS_N_13 TERM_OR_N_NS 0.03425f
C178 FS_P_BLEED_0 HS_N_1 0.06178f
C179 PULLUP_P_BLEED_3 PULLUP_P_BLEED_1 0.00855f
C180 FS_P_BLEED_5 FS_P_BLEED_4 3.61839f
C181 HS_N_6 HS_N_11 0
C182 TERM_P_R HS_P_10 0.14229f
C183 FS_N_BLEED_3 FS_HIGH_P 0
C184 PULLUP_P_BLEED_5 HS_N_4 0.02921f
C185 TERM_GATE_N_BLEED_0 HS_N_4 0.03489f
C186 TERM_GATE_P HS_P_6 0.15508f
C187 PULLUP_P_WELL HS_N 0.29467f
C188 HS_N_13 HS_N_0 0.07993f
C189 TERM_OR_N_S PULLUP_P 0.13572f
C190 HS_N_9 HS_N_8 0.11968p
C191 FS_N_GATE HS_N 2.07022f
C192 PULLUP_P_BLEED_3 PULLUP_P_BLEED_5 0.00153f
C193 PULLUP_N_GATE PULLUP_P 1.42018f
C194 DIV_N PAD_N 0.68859f
C195 FS_N_BLEED_3 PULLDOWN_N_R 0.08856f
C196 PULLUP_N_BLEED_2 PULLUP_N_BLEED_5 0.00296f
C197 HS_N_13 FS_N_WELL 0.00988f
C198 BYPASS_ENABLE DIV_LOW_P 0
C199 PULLUP_N_OUT PULLUP_P_WELL 0.6012f
C200 PULLUP_P_BLEED_5 HS_N_11 0.02434f
C201 PULLUP_P FS_LOW_N 0.06432f
C202 HS_N_3 HS_N_1 0.03945f
C203 HS_N_13 FS_P_WELL 1.99138f
C204 FS_N_GATE PULLUP_N_OUT 1.02928f
C205 PULLUP_P_OUT FS_N_OUT 0.06167f
C206 TERM_GATE_N_BLEED_0 HS_N_11 0.03489f
C207 DIV_LOW_N HS_N_1 0.06178f
C208 PULLUP_P_CONTROL_S HS_PBIAS 0.07486f
C209 HS_N_6 TERM_GATE_P 0.11785f
C210 FS_N_BLEED_5 FS_HIGH_P 0.01355f
C211 TERM_P_R PULLUP_N_BLEED_5 0.11141f
C212 HS_P PULLUP_N_BLEED_1 0.11785f
C213 TERM_N_R FS_LOW_P 0.16749f
C214 TERM_VCM HS_N_1 0.12324f
C215 HS_N_10 HS_N_1 0.12635p
C216 PULLUP_P_WELL TERM_ENABLE 2.34229f
C217 HS_N_13 FS_P_GATE 1.03609f
C218 HS_N_9 TERM_GATE_N_BLEED_2 0.04943f
C219 a_41005_131545# a_41005_131825# 0.03725f
C220 HS_P_7 PULLDOWN_N_R 0.02418f
C221 HS_N_7 TERM_OR_P_NS 0.00491f
C222 FS_N_GATE TERM_ENABLE 0.97699f
C223 PULLUP_N_BLEED_4 PULLUP_N_BLEED_5 3.06975f
C224 HS_P_12 PULLDOWN_N_R 0.02404f
C225 TERM_P_R TERM_OR_P_B 0.76857f
C226 FS_P_BLEED_0 HS_N_5 0.06178f
C227 HS_P_2 VDD 5.70329f
C228 HS_N_6 TERM_GATE_N 0.04962f
C229 TERM_OR_P_NS HS_P_3 0.02846f
C230 PULLUP_N_WELL VDD 25.2292f
C231 HS_N FS_HIGH_P 0.02498f
C232 FS_P_BLEED_5 PULLUP_P_GATE 0.01836f
C233 PAD_P HS_P_7 1.52213f
C234 HS_N_13 HS_P_13 0.0245f
C235 HS_P_12 PAD_P 1.66835f
C236 VCM_LOW_OK HS_P 0.06526f
C237 HS_P_2 HS_P_5 0.03142f
C238 TERM_OR_N_B TERM_VCM 0.10825f
C239 HS_N PULLDOWN_N_R 0.12564f
C240 PULLUP_N_OUT FS_HIGH_P 0.05082f
C241 DIV_N HS_PBIAS 0.14108f
C242 PULLUP_P_WELL HS_N_0 0.24542f
C243 a_53878_132665# ESD_RAIL 0.53916f
C244 TERM_OR_N_B PULLDOWN_P 0.04844f
C245 HS_N_9 PULLUP_P_BLEED_6 0.00148f
C246 HS_N_7 PAD_N 1.7635f
C247 HS_P_7 HS_P_9 0.00206f
C248 HS_P_8 PULLDOWN_N_R 0.06544f
C249 PAD_N RX_P 3.07596f
C250 HS_N_5 HS_P_4 0.13307f
C251 FS_N_GATE FS_N_WELL 0.2903p
C252 PULLUP_N_OUT PULLDOWN_N_R 0.08331f
C253 PULLUP_N_GATE PULLUP_N_WELL 33.5703f
C254 HS_N_3 HS_N_5 0.063f
C255 HS_N_6 FS_P_CONTROL_S 0.03226f
C256 TERM_GATE_N_BLEED_0 TERM_GATE_N 4.39906f
C257 DIV_LOW_N HS_N_5 0.06178f
C258 PULLUP_P_OUT PULLDOWN_P_R 0.13835f
C259 PULLUP_N_WELL FS_LOW_N 0.20869f
C260 TERM_P_R TERM_GATE_P_BLEED_2 0.06551f
C261 FS_N_BLEED_6 HS_PBIAS 0.09349f
C262 HS_N PAD_P 1.23865f
C263 PAD_N HS_P_3 0.257f
C264 FS_N_BLEED_0 VDD 0.04218f
C265 HS_P_2 HS_P_1 0.0568f
C266 TERM_VCM HS_N_5 0.12535f
C267 TERM_ENABLE FS_HIGH_P 0.01303f
C268 HS_N_10 HS_N_5 0
C269 TERM_OR_N_B HS_N_8 0
C270 PAD_P HS_P_8 1.09993f
C271 TERM_GATE_N_BLEED_2 HS_N_1 0.02451f
C272 DIV_N TERM_P_R 0
C273 HS_N_5 PULLDOWN_P 0.04428f
C274 HS_N_12 PAD_N 1.21768f
C275 HS_N HS_P_9 0.12189f
C276 PULLUP_N_OUT PAD_P 0.11127f
C277 TERM_GATE_P_BLEED_0 HS_P_4 0.02451f
C278 TERM_ENABLE PULLDOWN_N_R 0.07871f
C279 PULLUP_P_WELL FS_P_GATE 0
C280 HS_P_8 HS_P_9 30.3927f
C281 PULLUP_P_OUT HS_N_2 0.03489f
C282 DIV_P HS_P_6 0.03388f
C283 PULLUP_N_OUT HS_P_9 0.07928f
C284 PULLUP_P_BLEED_4 HS_N_3 0.0525f
C285 PULLUP_P_OUT HS_P_11 0.05519f
C286 TERM_OR_N_NS FS_HIGH_P 0.00369f
C287 HS_N_4 HS_P_12 0.07181f
C288 PULLUP_P_GATE PULLUP_P_BLEED_0 0.16374f
C289 HS_N_9 HS_N_13 0.08666f
C290 TERM_OR_P_S TERM_OR_P_B 1.83456f
C291 PULLUP_N_OUT PULLUP_N_CONTROL_S 0.004f
C292 a_41852_148519# ESD_RAIL 0.33756p
C293 TERM_OR_N_NS PULLDOWN_N_R 0.04764f
C294 a_53878_131545# ESD_RAIL 0.56772f
C295 VCM_LOW_OK FS_LOW_P 0.34798f
C296 FS_N_BLEED_0 FS_LOW_N 0.00206f
C297 HS_N_11 HS_P_12 0.06914f
C298 HS_N_0 FS_HIGH_P 0.02438f
C299 PULLUP_P_BLEED_4 HS_N_10 0.0527f
C300 HS_N_5 HS_N_8 0.04101f
C301 PULLUP_P FS_N_BLEED_2 0.10124f
C302 a_42245_90628# ESD_RAIL 0.24349p
C303 PULLUP_P_CONTROL_S PULLUP_P_GATE 1.18123f
C304 HS_N PULLDOWN_N 0.05791f
C305 FS_N_WELL FS_HIGH_P 1.71197f
C306 HS_N_6 PULLUP_P 0.07466f
C307 PULLUP_N DIFF_ENABLE 0.26007f
C308 HS_N_4 HS_N 1.43714f
C309 TERM_ENABLE HS_P_9 0.07435f
C310 HS_N_0 PULLDOWN_N_R 0.06832f
C311 HS_N_7 HS_PBIAS 9.64698f
C312 FS_P_WELL FS_HIGH_P 6.72442f
C313 PULLUP_P_BLEED_1 PULLUP_P 0.23767f
C314 FS_N_OUT FS_P_BLEED_5 0.05624f
C315 TERM_ENABLE PULLUP_N_CONTROL_S 0.07644f
C316 PULLDOWN_N_R FS_N_WELL 2.17394f
C317 PULLUP_P_BLEED_3 HS_N 0.04828f
C318 PULLUP_N_OUT HS_N_4 0.01742f
C319 DIV_N FS_P_BLEED_1 0.10151f
C320 TERM_GATE_P_BLEED_0 HS_N_8 0
C321 FS_P_WELL PULLDOWN_N_R 2.83843f
C322 HS_P_0 HS_P_10 2.2381f
C323 PULLUP_N_OUT PULLUP_P_BLEED_3 0.05476f
C324 HS_N_11 HS_N 5.51295f
C325 HS_P_3 HS_PBIAS 6.23881f
C326 PULLUP_P_OUT FS_P_OUT 0.56159f
C327 PULLUP_P_BLEED_4 HS_N_8 0.0525f
C328 FS_LOW_P HS_P 0.09863f
C329 TERM_GATE_P HS_P_7 0.15508f
C330 PULLUP_P_BLEED_5 PULLUP_P 0.15607f
C331 HS_N_0 PAD_P 0.14558f
C332 HS_P_12 TERM_GATE_P 0.16452f
C333 HS_N_12 HS_PBIAS 4.90809f
C334 PULLUP_N_OUT HS_N_11 0.01419f
C335 TERM_GATE_N_BLEED_2 HS_N_5 0.03089f
C336 TERM_GATE_N_BLEED_0 PULLUP_P 0.05462f
C337 FS_P_GATE FS_HIGH_P 5.63212f
C338 HS_N_7 TERM_P_R 0.10033f
C339 HS_N_4 TERM_ENABLE 0.04808f
C340 FS_LOW_P DIV_LOW_P 0.12545f
C341 HS_N_13 HS_N_1 0.04843f
C342 TERM_N_R FS_P_BLEED_0 0.11444f
C343 FS_P_GATE PULLDOWN_N_R 1.47723f
C344 HS_N PULLUP_N_BLEED_6 0.06167f
C345 HS_N_7 FS_P_BLEED_4 0.06246f
C346 TERM_P_R HS_P_3 0.12136f
C347 HS_N_9 PULLUP_P_WELL 0.14182f
C348 PULLUP_P_BLEED_3 TERM_ENABLE 0.05997f
C349 HS_N_9 FS_N_GATE 0.01367f
C350 DIV_N PULLUP_P_GATE 0.00178f
C351 HS_P_2 HS_P_6 0.06956f
C352 HS_N TERM_GATE_P 0.17562f
C353 TERM_OR_N_NS HS_N_4 0.03425f
C354 HS_N_11 TERM_ENABLE 0.04853f
C355 a_41005_131545# a_41005_132385# 0
C356 TERM_GATE_P HS_P_8 0.15508f
C357 HS_N_5 PULLUP_P_BLEED_6 0
C358 PULLUP_N_GATE PULLUP_N_BLEED_3 0.13233f
C359 HS_N_12 TERM_P_R 0.0597f
C360 PULLUP_N_OUT TERM_GATE_P 0.37427f
C361 TERM_N_R HS_P_4 0.05722f
C362 PULLUP_P_OUT TERM_GATE_P_BLEED_1 0.14929f
C363 HS_P_13 PULLDOWN_N_R 0.02404f
C364 TERM_OR_N_NS HS_N_11 0.03425f
C365 TERM_N_R HS_N_3 0.05893f
C366 HS_N_0 HS_N_4 0.04165f
C367 PULLUP_P_OUT VDD 3.24314f
C368 FS_P_BLEED_5 PULLDOWN_P_R 0.11255f
C369 HS_N_12 FS_P_BLEED_4 0.06178f
C370 PULLUP_N_WELL FS_N_BLEED_2 0
C371 PULLUP_P_BLEED_2 VDD 0.57693f
C372 HS_N_6 HS_P_2 0.03089f
C373 TERM_N_R DIV_LOW_N 0.14472f
C374 TERM_OR_P_B HS_P_0 0.09384f
C375 FS_N_OUT PULLUP_P_CONTROL_S 0.05082f
C376 PULLUP_P_BLEED_3 HS_N_0 0.03489f
C377 HS_N_7 FS_P_BLEED_1 0.03472f
C378 TERM_GATE_N HS_N 0.08686f
C379 TERM_ENABLE PULLUP_N_BLEED_6 0.06151f
C380 FS_P_WELL HS_N_4 1.9794f
C381 FS_N_OUT TERM_OR_P_B 0.05082f
C382 TERM_N_R TERM_VCM 17.5283f
C383 HS_P_13 PAD_P 1.35247f
C384 HS_N_0 HS_N_11 0.0421f
C385 TERM_N_R PULLDOWN_P 0.20782f
C386 PULLUP_P_BLEED_4 PULLUP_P_BLEED_6 0.00326f
C387 TERM_N_R HS_N_10 0.06034f
C388 TERM_ENABLE TERM_GATE_P 1.60491f
C389 PULLDOWN_P_R HS_P_10 0.07466f
C390 HS_N_11 FS_N_WELL 0.00889f
C391 HS_N_2 FS_P_BLEED_5 0.06178f
C392 PULLUP_N_OUT TERM_GATE_N 0.23412f
C393 DIV_LOW_N BYPASS_ENABLE 0.00106f
C394 HS_P_13 HS_P_9 0.04877f
C395 HS_N_13 HS_N_5 0.10387f
C396 FS_P_WELL HS_N_11 2.03147f
C397 FS_N_BLEED_3 PULLUP_P 0.10124f
C398 PULLUP_N VDD 0.00338f
C399 PULLUP_P_WELL HS_N_1 0.1499f
C400 HS_N_9 FS_HIGH_P 0.02404f
C401 HS_N_4 FS_P_GATE 1.03504f
C402 HS_N_12 FS_P_BLEED_1 0.03472f
C403 HS_N FS_P_CONTROL_S 0.04342f
C404 PULLUP_P_OUT FS_P_BLEED_3 0.00257f
C405 FS_N_BLEED_0 FS_N_BLEED_2 0.12309f
C406 TERM_VCM BYPASS_ENABLE 0.00889f
C407 HS_N_2 HS_P_10 0.03089f
C408 HS_N_9 PULLDOWN_N_R 0.02404f
C409 HS_P_11 HS_P_10 48.3384f
C410 TERM_N_R HS_N_8 0.05914f
C411 TERM_GATE_N TERM_ENABLE 10.756f
C412 FS_P_BLEED_2 FS_LOW_P 0.0781f
C413 HS_N_7 PULLUP_P_GATE 0.08496f
C414 PULLUP_N_BLEED_0 FS_HIGH_N 0.00933f
C415 DIV_N TERM_GATE_N_BLEED_1 0
C416 HS_N_0 TERM_GATE_P 0.11083f
C417 PULLUP_P_BLEED_0 PULLDOWN_P_R 0.01291f
C418 HS_N_11 FS_P_GATE 1.0396f
C419 DIV_N FS_N_OUT 0.07775f
C420 HS_N_13 PULLUP_P_BLEED_4 0.0525f
C421 PULLUP_N_GATE PULLUP_N 1.36429f
C422 HS_N_4 HS_P_13 0.02957f
C423 HS_P_12 DIV_P 0.03388f
C424 TERM_P_R TERM_OR_P_NS 0.22589f
C425 FS_P_BLEED_0 VCM_LOW_OK 0.15599f
C426 HS_N_9 PAD_P 1.20851f
C427 DIFF_ENABLE PULLUP_N_BLEED_5 0
C428 a_41005_131825# ESD_RAIL 0.53823f
C429 PULLUP_P_CONTROL_S PULLDOWN_P_R 0.08753f
C430 PULLDOWN_P PULLUP_N_BLEED_1 0.06517f
C431 HS_N_0 RX_N 0.00305f
C432 HS_N_12 PULLUP_P_GATE 0.08333f
C433 TERM_OR_P_B PULLDOWN_P_R 0.17949f
C434 HS_N_9 HS_P_9 0.06704f
C435 HS_N_11 HS_P_13 0.02487f
C436 PULLUP_P_CONTROL_S DIV_ENABLE 0.00795f
C437 TERM_GATE_N HS_N_0 0.05542f
C438 TERM_N_R TERM_GATE_N_BLEED_2 0.12212f
C439 TERM_OR_P_B DIV_ENABLE 0
C440 FS_HIGH_N HS_PBIAS 0.03743f
C441 HS_N DIV_P 0.08005f
C442 HS_N_1 FS_HIGH_P 0.03577f
C443 VCM_LOW_OK HS_P_4 0.06673f
C444 FS_P_BLEED_6 PULLUP_P_OUT 0.15208f
C445 HS_N_2 PULLUP_P_CONTROL_S 0.04855f
C446 HS_N PULLUP_P 0.03743f
C447 VCM_LOW_OK HS_N_3 0.05893f
C448 PULLUP_P_WELL HS_N_5 0.11805f
C449 FS_P_BLEED_0 HS_P 0.06178f
C450 HS_N_2 TERM_OR_P_B 0.07258f
C451 HS_N_1 PULLDOWN_N_R 0.02404f
C452 PULLUP_N_OUT PULLUP_P 29.6142f
C453 PULLUP_N_BLEED_0 HS_PBIAS 0.07928f
C454 TERM_OR_P_B HS_P_11 0.11938f
C455 HS_N_0 FS_P_CONTROL_S 0.03296f
C456 FS_N_BLEED_3 PULLUP_N_WELL 0
C457 TERM_P_R FS_HIGH_N 0.05398f
C458 VCM_LOW_OK TERM_VCM 0.10492p
C459 HS_N_9 HS_N_4 0.04068f
C460 HS_P_13 TERM_GATE_P 0.15775f
C461 VCM_LOW_OK PULLDOWN_P 0.04528f
C462 VCM_LOW_OK HS_N_10 0.05893f
C463 PULLUP_N_BLEED_0 PULLUP_N_BLEED_2 0.00326f
C464 HS_N_7 TERM_GATE_N_BLEED_1 0.0525f
C465 FS_P_WELL FS_P_CONTROL_S 0.18587f
C466 HS_N_9 PULLUP_P_BLEED_3 0.03489f
C467 HS_N_7 HS_P_0 0
C468 PAD_P HS_N_1 0.48214f
C469 RX_P HS_P_0 0
C470 HS_P HS_P_4 1.7567f
C471 PULLUP_P_WELL PULLUP_P_BLEED_4 0
C472 HS_N_3 HS_P 0.21103f
C473 HS_N_9 HS_N_11 0.02558f
C474 TERM_ENABLE PULLUP_P 0.04377f
C475 FS_N_OUT RX_P 0.01284f
C476 DIV_N DIV_ENABLE 33.0875f
C477 TERM_OR_P_S TERM_OR_P_NS 0.00736f
C478 DIV_LOW_N HS_P 0.06178f
C479 PULLUP_N_WELL FS_N_BLEED_5 0
C480 HS_P_3 HS_P_0 0.03772f
C481 VDD HS_P_10 6.63169f
C482 HS_P_2 HS_P_7 0.06184f
C483 TERM_OR_N_B PULLDOWN_N_R 0.04207f
C484 FS_N_BLEED_4 FS_HIGH_N 0.16623f
C485 a_41005_131545# a_41005_132945# 0
C486 FS_P_GATE FS_P_CONTROL_S 1.45056f
C487 VCM_LOW_OK HS_N_8 0.05893f
C488 PULLUP_N_BLEED_2 HS_PBIAS 0.01633f
C489 TERM_VCM HS_P 0.21204f
C490 HS_P_12 HS_P_2 0.00206f
C491 TERM_OR_N_NS PULLUP_P 0.05397f
C492 HS_N_12 HS_P_0 0.04378f
C493 HS_N_12 TERM_GATE_N_BLEED_1 0.05263f
C494 DIV_N HS_N_2 0.03462f
C495 FS_N_BLEED_3 FS_N_BLEED_0 0.10559f
C496 HS_N_10 HS_P 0.25322f
C497 HS_P_10 HS_P_5 0.0481f
C498 FS_P_OUT TERM_OR_P_B 0.16122f
C499 HS_N_0 DIV_P 0.03388f
C500 TERM_N_R HS_N_13 0.10989f
C501 TERM_VCM DIV_LOW_P 0.00257f
C502 PULLUP_P_OUT HS_N_6 0.03489f
C503 HS_N_5 FS_HIGH_P 0.02404f
C504 HS_N_10 DIV_LOW_P 0.00259f
C505 FS_P_BLEED_3 FS_P_BLEED_5 0.12036f
C506 HS_N_9 TERM_GATE_P 0.13605f
C507 HS_N_0 PULLUP_P 0.07466f
C508 TERM_P_R HS_PBIAS 0.44602f
C509 HS_N HS_P_2 0.46352f
C510 PULLUP_P FS_N_WELL 1.91861f
C511 PULLUP_P_BLEED_2 PULLUP_P_BLEED_1 2.37421f
C512 HS_N_5 PULLDOWN_N_R 0.06832f
C513 HS_N_4 HS_N_1 0
C514 PULLUP_N_WELL HS_N 0.46804f
C515 VDD PULLUP_N_BLEED_5 0.55431f
C516 VDD PULLUP_P_BLEED_0 0.05459f
C517 HS_P_2 HS_P_8 0.03103f
C518 FS_P_BLEED_4 HS_PBIAS 0.09926f
C519 PULLUP_N_OUT HS_P_2 0.07964f
C520 HS_P HS_N_8 0.55444f
C521 PULLUP_P_BLEED_3 HS_N_1 0.03489f
C522 HS_P_1 HS_P_10 37.0279f
C523 PULLUP_N_OUT PULLUP_N_WELL 30.7254f
C524 FS_LOW_P HS_P_4 0.04599f
C525 HS_N_11 HS_N_1 0.03414f
C526 PULLUP_P_BLEED_4 FS_HIGH_P 0.03577f
C527 HS_N_5 PAD_P 0.34243f
C528 HS_N_3 FS_LOW_P 0.08505f
C529 PULLUP_N_BLEED_4 PULLUP_N_BLEED_2 0.00234f
C530 PULLUP_P_CONTROL_S VDD 4.743f
C531 FS_P_BLEED_2 FS_P_BLEED_0 0
C532 FS_N_BLEED_4 HS_PBIAS 0.04811f
C533 TERM_GATE_P_BLEED_1 TERM_OR_P_B 0.00371f
C534 HS_N_7 PULLDOWN_P_R 0.02404f
C535 HS_N_9 TERM_GATE_N 0.05172f
C536 TERM_GATE_P_BLEED_0 PULLDOWN_N_R 0.0553f
C537 DIV_LOW_N FS_LOW_P 0.08856f
C538 PULLUP_P_BLEED_4 PULLDOWN_N_R 0.09196f
C539 PULLUP_N_GATE PULLUP_N_BLEED_5 0.24191f
C540 HS_N_7 DIV_ENABLE 0.03089f
C541 TERM_OR_P_B VDD 16.0128f
C542 DIV_N FS_P_OUT 0.05123f
C543 RX_P DIV_ENABLE 0.88297f
C544 TERM_ENABLE HS_P_2 0.06392f
C545 FS_LOW_P TERM_VCM 0.24801f
C546 VCM_LOW_OK PULLUP_P_BLEED_6 0
C547 HS_N_10 FS_LOW_P 0.08505f
C548 FS_N_BLEED_0 HS_N 0.11535f
C549 PULLUP_N_WELL TERM_ENABLE 0.52247f
C550 PULLUP_N_BLEED_4 TERM_P_R 0.04588f
C551 HS_P_3 PULLDOWN_P_R 0.07466f
C552 FS_P_BLEED_1 HS_PBIAS 0.04811f
C553 TERM_OR_P_B HS_P_5 0.10156f
C554 TERM_GATE_N_BLEED_2 HS_P 0.10446f
C555 HS_N_7 HS_N_2 0.02926f
C556 FS_P_BLEED_6 FS_P_BLEED_5 5.16949f
C557 HS_N_9 FS_P_CONTROL_S 0.03242f
C558 HS_N_12 PULLDOWN_P_R 0.02424f
C559 HS_N_7 HS_P_11 0
C560 FS_N_BLEED_4 TERM_P_R 0.04766f
C561 PULLUP_N_OUT FS_N_BLEED_0 0
C562 TERM_N_R PULLUP_P_WELL 0.33634f
C563 TERM_GATE_P HS_N_1 0.10974f
C564 a_41005_132385# ESD_RAIL 0.53823f
C565 HS_N_12 DIV_ENABLE 0.03143f
C566 TERM_OR_P_NS HS_P_0 0.07621f
C567 TERM_GATE_P_BLEED_0 HS_P_9 0.03888f
C568 TERM_N_R FS_N_GATE 0.76877f
C569 TERM_GATE_P_BLEED_2 TERM_GATE_P_BLEED_1 1.09058f
C570 HS_N_2 HS_P_3 0.02451f
C571 HS_N_4 HS_N_5 0.12253p
C572 HS_P_11 HS_P_3 0.02877f
C573 TERM_GATE_P_BLEED_2 VDD 0.084f
C574 FS_LOW_P HS_N_8 0.21311f
C575 TERM_OR_P_B HS_P_1 0.08191f
C576 PULLUP_P_BLEED_6 HS_P 0.00212f
C577 HS_N_2 HS_N_12 0.02585f
C578 FS_N_BLEED_1 HS_P 0.08856f
C579 TERM_P_R FS_P_BLEED_1 0.04766f
C580 HS_N_12 HS_P_11 0.11035f
C581 PULLUP_P_BLEED_3 HS_N_5 0.03489f
C582 DIV_N VDD 0.3598f
C583 FS_P_BLEED_2 HS_N_10 0
C584 PULLUP_P_WELL BYPASS_ENABLE 0.00823f
C585 PULLUP_P_GATE HS_PBIAS 0.17404f
C586 HS_N_13 VCM_LOW_OK 0.05893f
C587 TERM_GATE_N HS_N_1 0.05139f
C588 HS_N_11 HS_N_5 0
C589 TERM_OR_P_S TERM_P_R 2.01371f
C590 PAD_N HS_P_0 0.38312f
C591 DIV_N HS_P_5 0.01203f
C592 HS_N_4 PULLUP_P_BLEED_4 0.0525f
C593 FS_N_BLEED_6 VDD 0.00257f
C594 FS_N_OUT PAD_N 4.09186f
C595 HS_N_7 FS_P_OUT 0.52477f
C596 FS_P_OUT RX_P 0.01238f
C597 HS_P_6 HS_P_10 0.07646f
C598 PULLUP_P_BLEED_3 PULLUP_P_BLEED_4 6.29036f
C599 PULLUP_P_GATE TERM_P_R 0.15811f
C600 HS_N_9 PULLUP_P 0.02404f
C601 FS_N_OUT FS_HIGH_N 0.03054f
C602 HS_N_6 FS_P_BLEED_5 0.06178f
C603 FS_P_CONTROL_S HS_N_1 0.0324f
C604 DIV_N FS_LOW_N 0.03551f
C605 HS_N_11 PULLUP_P_BLEED_4 0.05266f
C606 TERM_N_R FS_HIGH_P 0.01124f
C607 HS_N_13 HS_P 0.10519f
C608 FS_P_OUT HS_P_3 0.09146f
C609 FS_N_BLEED_0 FS_N_WELL 2.72415f
C610 HS_N_5 TERM_GATE_P 0.11502f
C611 FS_P_BLEED_4 PULLUP_P_GATE 0
C612 TERM_OR_N_B TERM_GATE_N 1.45686f
C613 PULLUP_N_GATE FS_N_BLEED_6 0
C614 TERM_N_R PULLDOWN_N_R 0.12913f
C615 HS_N_12 FS_P_OUT 0.43801f
C616 HS_N_6 HS_P_10 0.03097f
C617 FS_N_BLEED_6 FS_LOW_N 0
C618 HS_N_13 DIV_LOW_P 0.00103f
C619 TERM_OR_P_NS PULLDOWN_P_R 0.05654f
C620 HS_P_13 HS_P_2 36.317f
C621 FS_LOW_P FS_N_BLEED_1 0.23767f
C622 a_41005_134065# m2_42279_124800# 0
C623 BYPASS_ENABLE FS_HIGH_P 0
C624 HS_N_7 VDD 5.51673f
C625 TERM_GATE_P_BLEED_0 TERM_GATE_P 4.84915f
C626 TERM_N_R PAD_P 0.19266f
C627 TERM_GATE_N HS_N_5 0.04924f
C628 PULLUP_P_WELL VCM_LOW_OK 0.26131f
C629 PULLUP_P_OUT HS_N 0.04828f
C630 PULLUP_N_BLEED_3 TERM_ENABLE 0.01168f
C631 TERM_OR_P_NS HS_P_11 0.04285f
C632 TERM_GATE_N_BLEED_1 HS_PBIAS 0.07928f
C633 HS_P_0 HS_PBIAS 0.94883f
C634 PULLUP_P_GATE FS_P_BLEED_1 0.00424f
C635 PULLUP_P_OUT HS_P_8 0.00135f
C636 PAD_N PULLDOWN_P_R 0.0844f
C637 FS_N_OUT HS_PBIAS 0.93576f
C638 VDD HS_P_3 6.14484f
C639 HS_N_7 HS_P_5 0.03489f
C640 TERM_N_R PULLUP_N_CONTROL_S 0.05859f
C641 PULLUP_P_OUT PULLUP_N_OUT 0.17355f
C642 FS_P_BLEED_0 HS_N_3 0.06178f
C643 TERM_OR_P_B HS_P_6 0.10133f
C644 PULLUP_P HS_N_1 0.02404f
C645 PULLUP_P_BLEED_2 PULLUP_N_OUT 0
C646 PAD_N DIV_ENABLE 0.03382f
C647 BYPASS_ENABLE PAD_P 8.2284f
C648 PULLUP_P_BLEED_1 PULLUP_P_BLEED_0 0.83843f
C649 HS_N_12 VDD 6.63266f
C650 HS_N_7 TERM_OR_N_S 0.02895f
C651 FS_N_CONTROL_S FS_HIGH_N 7.6088f
C652 FS_P_CONTROL_S HS_N_5 0.03226f
C653 HS_P_3 HS_P_5 0.03192f
C654 HS_N_13 FS_LOW_P 0.08505f
C655 DIV_ENABLE FS_HIGH_N 3.66887f
C656 HS_N_7 FS_LOW_N 0.08486f
C657 HS_N_9 HS_P_2 0.03089f
C658 FS_P_BLEED_0 TERM_VCM 0.09235f
C659 PULLUP_N_BLEED_1 PULLDOWN_N_R 0.07928f
C660 PULLUP_P_WELL HS_P 0.18882f
C661 HS_N_2 PAD_N 1.16258f
C662 HS_N_6 PULLUP_P_CONTROL_S 0.04808f
C663 FS_P_BLEED_0 HS_N_10 0.06178f
C664 TERM_P_R HS_P_0 0.07626f
C665 TERM_N_R PULLDOWN_N 0.05478f
C666 HS_N_6 TERM_OR_P_B 0.07211f
C667 PAD_N HS_P_11 1.42473f
C668 HS_N_12 HS_P_5 0.03489f
C669 HS_N_7 FS_P_BLEED_3 0.03794f
C670 PULLUP_P_OUT TERM_ENABLE 11.6132f
C671 FS_N_OUT TERM_P_R 0.3082f
C672 HS_N_7 HS_P_1 0
C673 TERM_N_R HS_N_4 0.05893f
C674 FS_N_GATE HS_P 1.48197f
C675 FS_HIGH_N DIFF_ENABLE 0.2667f
C676 HS_N_12 TERM_OR_N_S 0.02482f
C677 PULLUP_P_BLEED_2 TERM_ENABLE 0.11229f
C678 PAD_P ESD_RAIL 24.1165f
C679 PULLUP_N_OUT PULLUP_N 0.03945f
C680 TERM_N_R PULLUP_P_BLEED_3 0.06105f
C681 PULLUP_N_BLEED_0 DIV_ENABLE 0
C682 FS_N_OUT FS_P_BLEED_4 0.06639f
C683 TERM_OR_N_B PULLUP_P 0.09232f
C684 HS_P_1 HS_P_3 0.06154f
C685 DIV_LOW_N HS_N_3 0.06178f
C686 HS_N_12 FS_LOW_N 0.08441f
C687 TERM_N_R HS_N_11 0.05996f
C688 TERM_VCM HS_P_4 0.12461f
C689 VCM_LOW_OK FS_HIGH_P 0.02051f
C690 FS_P_BLEED_3 HS_N_12 0.02888f
C691 a_41005_132945# ESD_RAIL 0.53823f
C692 FS_P_BLEED_0 HS_N_8 0.06178f
C693 HS_N_3 TERM_VCM 0.12325f
C694 DIV_N HS_P_6 0
C695 HS_N_3 HS_N_10 0.03951f
C696 DIV_LOW_N TERM_VCM 0.19527f
C697 PULLUP_P_OUT HS_N_0 0.03489f
C698 VCM_LOW_OK PULLDOWN_N_R 0.09227f
C699 DIV_LOW_N PULLDOWN_P 0.08856f
C700 DIV_LOW_N HS_N_10 0.06178f
C701 TERM_ENABLE PULLUP_N 0.01513f
C702 PULLUP_P_BLEED_3 BYPASS_ENABLE 0.00766f
C703 FS_N_CONTROL_S HS_PBIAS 0.09439f
C704 PULLDOWN_P_R HS_PBIAS 0.50594f
C705 HS_N_5 PULLUP_P 0.0678f
C706 TERM_VCM PULLDOWN_P 0.18094f
C707 HS_N_10 TERM_VCM 0.12019f
C708 DIV_ENABLE HS_PBIAS 0.05806f
C709 PULLUP_P_OUT FS_P_WELL 3.0456f
C710 FS_P_OUT PAD_N 1.89403f
C711 DIV_N HS_N_6 0.03462f
C712 TERM_N_R PULLUP_N_BLEED_6 0.06125f
C713 FS_N_OUT FS_P_BLEED_1 0.36323f
C714 HS_P_2 HS_N_1 0.00649f
C715 HS_N_8 HS_P_4 0.02404f
C716 HS_N_3 HS_N_8 0.03258f
C717 FS_P_BLEED_6 HS_N_7 0.06178f
C718 HS_P FS_HIGH_P 0.02404f
C719 VCM_LOW_OK PAD_P 0.00567f
C720 DIFF_ENABLE HS_PBIAS 0.27859f
C721 TERM_N_R TERM_GATE_P 1.39719f
C722 PULLUP_P_WELL FS_LOW_P 0.27223f
C723 TERM_OR_P_NS VDD 0.04366f
C724 FS_N_GATE FS_LOW_P 0.45819f
C725 HS_N_2 HS_PBIAS 1.31428f
C726 DIV_LOW_N HS_N_8 0.06178f
C727 VCM_LOW_OK HS_P_9 0.0458f
C728 HS_P_11 HS_PBIAS 9.38284f
C729 FS_N_CONTROL_S TERM_P_R 0.11557f
C730 HS_P PULLDOWN_N_R 0.08383f
C731 TERM_P_R PULLDOWN_P_R 0.16322f
C732 PULLUP_P_OUT FS_P_GATE 1.53435f
C733 TERM_P_R DIV_ENABLE 0.05603f
C734 PULLUP_N_BLEED_6 BYPASS_ENABLE 0.00766f
C735 TERM_VCM HS_N_8 0.13427f
C736 TERM_OR_P_NS HS_P_5 0.02846f
C737 PULLUP_P_BLEED_4 PULLUP_P 0.16921f
C738 DIV_N TERM_GATE_N_BLEED_0 0.10151f
C739 HS_N_10 HS_N_8 0.04444f
C740 HS_P_7 HS_P_10 0.10683f
C741 HS_P_12 HS_P_10 0.07589f
C742 FS_P_BLEED_6 HS_N_12 0.06178f
C743 FS_P_BLEED_4 PULLDOWN_P_R 0.08089f
C744 TERM_P_R DIFF_ENABLE 4.25629f
C745 TERM_N_R TERM_GATE_N 26.1022f
C746 FS_P_BLEED_5 HS_N 0.08043f
C747 FS_N_OUT PULLUP_P_GATE 0.1125f
C748 PAD_P HS_P 39.8004f
C749 TERM_GATE_N_BLEED_2 HS_N_3 0.02807f
C750 HS_N_2 TERM_P_R 0.0594f
C751 PAD_N VDD 0.00457f
C752 TERM_P_R HS_P_11 0.14852f
C753 FS_P_BLEED_2 PULLUP_P_WELL 0
C754 PULLUP_N_OUT FS_P_BLEED_5 0.05922f
C755 HS_P HS_P_9 6.36218f
C756 HS_N_7 HS_P_6 0.02536f
C757 HS_N_4 VCM_LOW_OK 0.05893f
C758 RX_N BYPASS_ENABLE 7.32117f
C759 TERM_OR_P_NS HS_P_1 0.04312f
C760 FS_N_BLEED_4 DIV_ENABLE 0.03564f
C761 HS_N HS_P_10 0.34498f
C762 PULLUP_N_BLEED_6 PULLUP_N_BLEED_1 0.00257f
C763 HS_N_2 FS_P_BLEED_4 0.06178f
C764 FS_HIGH_N VDD 0.2016f
C765 TERM_GATE_N_BLEED_2 TERM_VCM 0.02153f
C766 PULLUP_P_BLEED_3 VCM_LOW_OK 0.03823f
C767 HS_P_3 HS_P_6 0.07261f
C768 PAD_N HS_P_5 1.55482f
C769 TERM_GATE_N_BLEED_2 PULLDOWN_P 0.07928f
C770 TERM_GATE_N_BLEED_2 HS_N_10 0.02441f
C771 HS_P_8 HS_P_10 0.00926f
C772 a_44789_117064# a_43813_117064# 3.03168f
C773 PULLUP_N_OUT HS_P_10 0.08961f
C774 FS_P_OUT HS_PBIAS 0.96844f
C775 HS_N_5 HS_P_2 0.03089f
C776 HS_N_7 HS_N_6 0.12041p
C777 HS_N_11 VCM_LOW_OK 0.05893f
C778 PULLDOWN_P_R FS_P_BLEED_1 0.05445f
C779 FS_LOW_P FS_HIGH_P 8.96385f
C780 HS_N_12 HS_P_6 0.05906f
C781 DIV_ENABLE FS_P_BLEED_1 0.01375f
C782 FS_P_BLEED_5 TERM_ENABLE 0.00492f
C783 FS_LOW_P PULLDOWN_N_R 0.0629f
C784 PULLUP_N_BLEED_0 VDD 0
C785 HS_N_6 HS_P_3 0.03089f
C786 HS_N_4 HS_P 0.33321f
C787 HS_P PULLDOWN_N 0.03743f
C788 PULLUP_N_GATE FS_HIGH_N 0.01195f
C789 HS_N_13 FS_P_BLEED_0 0.06178f
C790 TERM_OR_P_B HS_P_7 0.10117f
C791 PAD_N HS_P_1 0.56708f
C792 FS_N_BLEED_1 PULLDOWN_P 0.09712f
C793 FS_HIGH_N FS_LOW_N 0.08748f
C794 TERM_GATE_N_BLEED_2 HS_N_8 0.04243f
C795 HS_P_12 TERM_OR_P_B 0.13059f
C796 HS_N_2 FS_P_BLEED_1 0.03472f
C797 PULLUP_P_BLEED_6 PULLDOWN_P 0.09848f
C798 FS_P_OUT TERM_P_R 0.43231f
C799 TERM_ENABLE HS_P_10 0.0768f
C800 PULLUP_P_BLEED_3 HS_P 0.03489f
C801 TERM_GATE_P_BLEED_0 HS_P_2 0.02483f
C802 HS_N_7 PULLUP_P_BLEED_5 0.03702f
C803 HS_N_6 HS_N_12 0
C804 HS_N_7 TERM_GATE_N_BLEED_0 0.03489f
C805 PULLUP_P_OUT HS_N_9 0.03516f
C806 HS_N_11 HS_P 0.77257f
C807 PULLUP_N_OUT PULLUP_P_BLEED_0 0.04637f
C808 FS_P_BLEED_2 FS_HIGH_P 0.03577f
C809 VCM_LOW_OK TERM_GATE_P 0.20188f
C810 PULLUP_P_GATE PULLDOWN_P_R 0.39874f
C811 PULLUP_N_BLEED_0 PULLUP_N_GATE 0.05192f
C812 FS_P_BLEED_5 HS_N_0 0.06178f
C813 PULLUP_P_GATE DIV_ENABLE 0
C814 FS_LOW_P HS_P_9 0.05657f
C815 FS_N_OUT TERM_GATE_N_BLEED_1 0.06408f
C816 a_41005_131545# a_44789_117064# 0.02926f
C817 PULLUP_P_CONTROL_S HS_N 0.11565f
C818 VDD HS_PBIAS 83.74921f
C819 HS_N_13 HS_N_3 0.279f
C820 HS_N_11 DIV_LOW_P 0.00184f
C821 PULLUP_N_BLEED_0 FS_LOW_N 0.08389f
C822 HS_N TERM_OR_P_B 0.1311f
C823 TERM_N_R PULLUP_P 0.34532f
C824 HS_N_12 PULLUP_P_BLEED_5 0.02427f
C825 PULLUP_N_OUT PULLUP_P_CONTROL_S 0.08753f
C826 HS_N_13 DIV_LOW_N 0.06178f
C827 TERM_GATE_N_BLEED_0 HS_N_12 0.03489f
C828 TERM_OR_P_B HS_P_8 0.10057f
C829 PULLUP_P_BLEED_6 HS_N_8 0.00108f
C830 PULLUP_N_OUT TERM_OR_P_B 0.20772f
C831 HS_P_5 HS_PBIAS 3.80328f
C832 TERM_ENABLE PULLUP_N_BLEED_5 0.11535f
C833 HS_N_2 PULLUP_P_GATE 0.08296f
C834 TERM_ENABLE PULLUP_P_BLEED_0 0.00606f
C835 PULLUP_N_BLEED_6 HS_P 0.04828f
C836 a_41005_133505# ESD_RAIL 0.53842f
C837 HS_N_13 TERM_VCM 0.17f
C838 HS_N_13 HS_N_10 0.09129f
C839 TERM_GATE_N VCM_LOW_OK 0.01725f
C840 HS_N_13 PULLDOWN_P 0.04428f
C841 HS_P TERM_GATE_P 0.22621f
C842 TERM_P_R TERM_GATE_P_BLEED_1 0.00257f
C843 PULLUP_N_GATE HS_PBIAS 0.14584f
C844 TERM_OR_N_S HS_PBIAS 0.12657f
C845 BYPASS_ENABLE DIV_P 0.05958f
C846 TERM_P_R VDD 6.53315f
C847 DIV_N HS_P_12 0.01246f
C848 FS_P_OUT FS_P_BLEED_1 0
C849 FS_LOW_N HS_PBIAS 0.39667f
C850 HS_N_4 FS_LOW_P 0.08505f
C851 FS_P_BLEED_5 FS_P_GATE 0.31234f
C852 PULLUP_N_GATE PULLUP_N_BLEED_2 0.06702f
C853 TERM_OR_P_NS HS_P_6 0.02846f
C854 FS_N_BLEED_6 FS_N_BLEED_5 1.15313f
C855 TERM_GATE_P DIV_LOW_P 0.00428f
C856 PULLUP_P_CONTROL_S TERM_ENABLE 0
C857 TERM_P_R HS_P_5 0.08374f
C858 HS_P_1 HS_PBIAS 2.59892f
C859 FS_P_BLEED_3 HS_PBIAS 0.07855f
C860 PULLUP_P_WELL FS_P_BLEED_0 0
C861 a_41005_131825# a_41005_132385# 0.0346f
C862 TERM_ENABLE TERM_OR_P_B 5.36669f
C863 PULLUP_P_OUT HS_N_1 0.03489f
C864 PULLUP_P_BLEED_3 FS_LOW_P 0.07139f
C865 PULLUP_N_BLEED_4 VDD 0.0157f
C866 HS_N_11 FS_LOW_P 0.08505f
C867 PULLUP_N_GATE TERM_P_R 0.15782f
C868 TERM_P_R TERM_OR_N_S 0.30551f
C869 HS_N_13 HS_N_8 0.16699f
C870 DIV_N HS_N 0.0509f
C871 TERM_GATE_N HS_P 0.05324f
C872 FS_N_BLEED_4 VDD 0.45117f
C873 HS_N_6 TERM_OR_P_NS 0.00351f
C874 TERM_P_R FS_LOW_N 0.03634f
C875 DIV_N PULLUP_N_OUT 0.04377f
C876 PULLDOWN_P_R HS_P_0 0.03037f
C877 TERM_P_R HS_P_1 0.10249f
C878 PULLUP_P_CONTROL_S HS_N_0 0.05093f
C879 PULLUP_N_BLEED_4 PULLUP_N_GATE 0.20501f
C880 PAD_N HS_P_6 0.31264f
C881 FS_N_BLEED_6 HS_N 0.07097f
C882 TERM_GATE_N_BLEED_1 DIV_ENABLE 0
C883 FS_N_OUT FS_N_CONTROL_S 0.01993f
C884 PULLUP_P_WELL HS_N_3 0.11601f
C885 HS_N_0 TERM_OR_P_B 0.07497f
C886 HS_P_13 HS_P_10 0.09466f
C887 VDD FS_P_BLEED_1 0.44675f
C888 TERM_ENABLE TERM_GATE_P_BLEED_2 0.07306f
C889 FS_LOW_P PULLUP_N_BLEED_6 0.06116f
C890 FS_N_OUT DIV_ENABLE 0.15376f
C891 FS_P_CONTROL_S HS_P 0.03246f
C892 FS_N_BLEED_4 PULLUP_N_GATE 0.00498f
C893 FS_P_BLEED_3 FS_P_BLEED_4 2.07149f
C894 FS_LOW_P TERM_GATE_P 0.15357f
C895 TERM_N_R PULLUP_N_WELL 0.3392f
C896 TERM_GATE_N_BLEED_2 HS_N_13 0.02404f
C897 FS_P_BLEED_2 HS_N_11 0
C898 DIV_N TERM_ENABLE 0.00368f
C899 FS_N_BLEED_4 FS_LOW_N 0.07141f
C900 HS_N_2 HS_P_0 0.03722f
C901 PULLUP_P_WELL TERM_VCM 0.28547f
C902 HS_N_2 TERM_GATE_N_BLEED_1 0.0525f
C903 HS_P_11 HS_P_0 0.06445f
C904 HS_N_6 PAD_N 1.1595f
C905 FS_N_GATE TERM_VCM 0.90423f
C906 TERM_OR_P_S VDD 4.39982f
C907 PULLUP_P_WELL HS_N_10 0.14098f
C908 HS_N_7 HS_P_12 0.03489f
C909 HS_N_7 HS_P_7 0
C910 FS_N_GATE PULLDOWN_P 1.24942f
C911 FS_N_GATE HS_N_10 0.00893f
C912 FS_P_BLEED_6 HS_PBIAS 0.08856f
C913 VCM_LOW_OK DIV_P 0.00892f
C914 FS_HIGH_N FS_N_BLEED_2 0.00429f
C915 FS_P_BLEED_0 FS_HIGH_P 0.23079f
C916 DIV_N TERM_OR_N_NS 0
C917 VCM_LOW_OK PULLUP_P 0.08753f
C918 HS_P_3 HS_P_7 0.06116f
C919 PULLUP_N_WELL BYPASS_ENABLE 0.01588f
C920 HS_N_9 FS_P_BLEED_5 0.06178f
C921 PULLUP_P_OUT HS_N_5 0.03489f
C922 HS_P_12 HS_P_3 0.02899f
C923 FS_P_BLEED_0 PULLDOWN_N_R 0.10124f
C924 PULLUP_P_GATE VDD 13.1722f
C925 TERM_GATE_N FS_LOW_P 0.04939f
C926 DIV_N HS_N_0 0.03952f
C927 PULLUP_P_WELL HS_N_8 0.13083f
C928 HS_N_7 HS_N 0.69419f
C929 HS_N_12 HS_P_12 0.08272f
C930 FS_P_BLEED_6 TERM_P_R 0.04565f
C931 FS_N_GATE HS_N_8 0.00226f
C932 HS_N_9 HS_P_10 0.03109f
C933 HS_P DIV_P 0.08005f
C934 HS_N_7 PULLUP_N_OUT 0.05812f
C935 DIV_N FS_P_WELL 0.86039f
C936 HS_N_3 FS_HIGH_P 0.02404f
C937 PULLUP_P_OUT TERM_GATE_P_BLEED_0 0.1011f
C938 HS_N HS_P_3 0.27803f
C939 HS_P_13 TERM_OR_P_B 0.10389f
C940 HS_P_6 HS_PBIAS 2.09103f
C941 HS_P PULLUP_P 0.02404f
C942 FS_P_BLEED_6 FS_P_BLEED_4 0.12309f
C943 PULLDOWN_N_R HS_P_4 0.07217f
C944 DIV_LOW_N FS_HIGH_P 0.16534f
C945 HS_N_3 PULLDOWN_N_R 0.02404f
C946 FS_P_OUT HS_P_0 0.09146f
C947 PULLUP_N_WELL PULLUP_N_BLEED_1 0.00587f
C948 HS_P_3 HS_P_8 0.03109f
C949 DIV_LOW_P DIV_P 0.50398f
C950 PULLUP_P_BLEED_2 PULLUP_P_BLEED_4 0
C951 DIV_LOW_N PULLDOWN_N_R 0.08856f
C952 PULLUP_N_OUT HS_P_3 0.08633f
C953 HS_N_12 HS_N 8.83112f
C954 TERM_VCM FS_HIGH_P 0.13992f
C955 FS_N_BLEED_2 HS_PBIAS 0.08856f
C956 HS_N_10 FS_HIGH_P 0.02442f
C957 FS_N_OUT FS_P_OUT 1.00178f
C958 FS_P_BLEED_3 PULLUP_P_GATE 0
C959 PULLUP_N_OUT HS_N_12 0.04377f
C960 TERM_VCM PULLDOWN_N_R 0.28542f
C961 HS_N_7 TERM_ENABLE 0.10575f
C962 HS_N_6 HS_PBIAS 7.23511f
C963 DIV_N FS_P_GATE 0.09711f
C964 DIV_ENABLE DIFF_ENABLE 5.44387f
C965 PULLDOWN_P PULLDOWN_N_R 88.8288f
C966 HS_N_10 PULLDOWN_N_R 0.02404f
C967 PAD_P HS_P_4 1.13663f
C968 HS_N_2 PULLDOWN_P_R 0.02404f
C969 FS_P_BLEED_5 HS_N_1 0.06178f
C970 TERM_P_R HS_P_6 0.08356f
C971 HS_P_11 PULLDOWN_P_R 0.07466f
C972 HS_N_3 PAD_P 0.09104f
C973 HS_N_2 DIV_ENABLE 0.03089f
C974 HS_P_9 HS_P_4 0.042f
C975 HS_N_7 TERM_OR_N_NS 0.03425f
C976 TERM_ENABLE HS_P_3 0.0768f
C977 VCM_LOW_OK HS_P_2 0.03489f
C978 FS_P_BLEED_0 HS_N_4 0.06178f
C979 HS_N_8 FS_HIGH_P 0.03528f
C980 TERM_P_R FS_N_BLEED_2 0.04588f
C981 PULLUP_P_BLEED_5 HS_PBIAS 0.17636f
C982 TERM_VCM PAD_P 0.0037f
C983 HS_N_9 PULLUP_P_CONTROL_S 0.04808f
C984 HS_N_10 PAD_P 0.11949f
C985 HS_N_12 TERM_ENABLE 0.08984f
C986 HS_N_1 HS_P_10 0.0348f
C987 HS_N_6 TERM_P_R 0.0959f
C988 HS_N_2 HS_P_11 0.03089f
C989 TERM_GATE_N_BLEED_0 HS_PBIAS 0.04828f
C990 VDD HS_P_0 3.95338f
C991 HS_N_9 TERM_OR_P_B 0.07254f
C992 HS_N_8 PULLDOWN_N_R 0.02404f
C993 HS_N_7 HS_N_0 0.07359f
C994 FS_N_GATE FS_N_BLEED_1 0.29846f
C995 FS_LOW_P DIV_P 2.36145f
C996 TERM_VCM HS_P_9 0.1405f
C997 PULLUP_P_BLEED_1 TERM_P_R 0.04588f
C998 TERM_OR_P_NS HS_P_7 0.02846f
C999 FS_N_OUT VDD 11.0129f
C1000 FS_P_BLEED_0 HS_N_11 0.06178f
C1001 HS_P_12 TERM_OR_P_NS 0.03931f
C1002 TERM_VCM PULLUP_N_CONTROL_S 0.0423f
C1003 FS_LOW_P PULLUP_P 0.10849f
C1004 HS_N_6 FS_P_BLEED_4 0.06231f
C1005 HS_N_12 TERM_OR_N_NS 0.03425f
C1006 HS_N_7 FS_P_WELL 1.98759f
C1007 HS_P_0 HS_P_5 0.00297f
C1008 HS_N_4 HS_P_4 0
C1009 HS_N_0 HS_P_3 0.02686f
C1010 FS_N_BLEED_3 FS_HIGH_N 0
C1011 HS_N_4 HS_N_3 0.12319p
C1012 FS_N_BLEED_4 FS_N_BLEED_2 0.00855f
C1013 FS_N_OUT HS_P_5 0.06167f
C1014 PAD_P HS_N_8 0.43522f
C1015 FS_P_BLEED_6 PULLUP_P_GATE 0.023f
C1016 HS_P HS_P_2 7.07711f
C1017 FS_P_OUT PULLDOWN_P_R 0.73833f
C1018 HS_N_12 HS_N_0 0.04188f
C1019 PULLUP_N_WELL HS_P 0.25435f
C1020 DIV_LOW_N HS_N_4 0.06178f
C1021 TERM_GATE_N_BLEED_0 TERM_P_R 0.04766f
C1022 PULLUP_P_BLEED_3 HS_N_3 0.03489f
C1023 TERM_GATE_N_BLEED_1 FS_LOW_N 0.0839f
C1024 FS_P_OUT DIV_ENABLE 0.0629f
C1025 HS_P_9 HS_N_8 0.00649f
C1026 HS_N_12 FS_N_WELL 0.00912f
C1027 TERM_GATE_N_BLEED_2 PULLDOWN_N_R 0.07928f
C1028 HS_N_4 TERM_VCM 0.12411f
C1029 PULLDOWN_N PULLDOWN_P 2.04789f
C1030 HS_N_4 HS_N_10 0
C1031 FS_P_WELL HS_N_12 2.00803f
C1032 HS_N_13 PULLUP_P_WELL 0.12105f
C1033 HS_N_7 FS_P_GATE 1.04462f
C1034 HS_N_11 HS_N_3 0.03962f
C1035 FS_N_OUT FS_LOW_N 0.31306f
C1036 HS_N_4 PULLDOWN_P 0.05303f
C1037 TERM_OR_P_NS HS_P_8 0.02846f
C1038 HS_P_1 HS_P_0 36.4065f
C1039 PAD_N HS_P_7 0.3613f
C1040 DIV_N HS_N_9 0.03462f
C1041 HS_N_13 FS_N_GATE 0.19342f
C1042 HS_P_12 PAD_N 0.22324f
C1043 FS_P_BLEED_5 HS_N_5 0.06178f
C1044 PULLUP_P_OUT TERM_N_R 0.09296f
C1045 PULLUP_N_OUT TERM_OR_P_NS 0.11021f
C1046 DIV_LOW_N HS_N_11 0.06178f
C1047 HS_N_2 FS_P_OUT 0.43576f
C1048 FS_HIGH_N FS_N_BLEED_5 0.00933f
C1049 FS_N_OUT FS_P_BLEED_3 0.08101f
C1050 PULLUP_P_BLEED_3 HS_N_10 0.03489f
C1051 HS_N_6 FS_P_BLEED_1 0.03472f
C1052 PULLUP_P_BLEED_3 TERM_VCM 0.03472f
C1053 PULLUP_P_CONTROL_S HS_N_1 0.05002f
C1054 PULLUP_P_BLEED_2 TERM_N_R 0.11444f
C1055 a_44789_117064# ESD_RAIL 16.8853f
C1056 FS_N_BLEED_1 FS_HIGH_P 0
C1057 TERM_OR_P_B HS_N_1 0.07438f
C1058 HS_N_11 TERM_VCM 0.12019f
C1059 HS_N_11 PULLDOWN_P 0.05266f
C1060 HS_N_11 HS_N_10 0.13802p
C1061 HS_N_5 HS_P_10 0.03089f
C1062 FS_N_BLEED_0 HS_P 0.09016f
C1063 HS_N_12 FS_P_GATE 1.03841f
C1064 PULLUP_P_BLEED_6 PULLDOWN_N_R 0.05779f
C1065 HS_N_7 HS_P_13 0.02404f
C1066 FS_N_BLEED_1 PULLDOWN_N_R 0.09111f
C1067 PULLUP_N_BLEED_3 PULLUP_N_BLEED_1 0.06528f
C1068 HS_N_4 HS_N_8 0.04079f
C1069 TERM_GATE_P_BLEED_1 PULLDOWN_P_R 0.01413f
C1070 HS_N PAD_N 35.6371f
C1071 TERM_GATE_P HS_P_4 0.15627f
C1072 FS_N_BLEED_3 HS_PBIAS 0.08856f
C1073 TERM_ENABLE TERM_OR_P_NS 0.1642f
C1074 FS_N_CONTROL_S VDD 3.02358f
C1075 HS_N_3 TERM_GATE_P 0.11104f
C1076 VDD PULLDOWN_P_R 1.92312f
C1077 PAD_N HS_P_8 0.85512f
C1078 DIV_ENABLE VDD 0.3424f
C1079 PULLUP_P_BLEED_3 HS_N_8 0.03489f
C1080 PULLUP_N_OUT PAD_N 1.29311f
C1081 HS_P_13 HS_P_3 0.2651f
C1082 TERM_N_R PULLUP_N 0.12734f
C1083 FS_LOW_P HS_P_2 0.04618f
C1084 HS_N_6 PULLUP_P_GATE 0.08451f
C1085 HS_N FS_HIGH_N 0.06561f
C1086 TERM_VCM PULLUP_N_BLEED_6 0.04263f
C1087 PULLUP_N_BLEED_6 PULLDOWN_P 0.04122f
C1088 HS_N_11 HS_N_8 0.03489f
C1089 PULLDOWN_P_R HS_P_5 0.02404f
C1090 DIFF_ENABLE VDD 0.45362f
C1091 TERM_GATE_P_BLEED_0 HS_P_10 0.03777f
C1092 PULLUP_N_WELL FS_LOW_P 0.28858f
C1093 TERM_VCM TERM_GATE_P 26.4481f
C1094 HS_N_10 TERM_GATE_P 0.10903f
C1095 DIV_ENABLE HS_P_5 0.00252f
C1096 PULLUP_P_GATE PULLUP_P_BLEED_1 0.19163f
C1097 HS_N_12 HS_P_13 0.02465f
C1098 PULLUP_N_OUT FS_HIGH_N 0.04377f
C1099 HS_N_2 VDD 5.27157f
C1100 HS_P_11 VDD 5.06957f
C1101 FS_N_BLEED_3 TERM_P_R 0.11141f
C1102 FS_P_BLEED_0 FS_P_CONTROL_S 0.00276f
C1103 HS_N_13 FS_HIGH_P 0.02404f
C1104 TERM_GATE_N_BLEED_2 HS_N_4 0.02921f
C1105 DIV_N HS_N_1 0.03462f
C1106 PULLUP_N_GATE DIV_ENABLE 0
C1107 TERM_GATE_N HS_N_3 0.04808f
C1108 FS_LOW_N PULLDOWN_P_R 0.00223f
C1109 PULLUP_N_BLEED_0 HS_N 0.12943f
C1110 FS_P_BLEED_6 FS_N_OUT 0.04877f
C1111 PULLUP_P_GATE PULLUP_P_BLEED_5 0.2056f
C1112 DIV_LOW_N TERM_GATE_N 0.06956f
C1113 HS_P_7 HS_PBIAS 0.78499f
C1114 HS_N_2 HS_P_5 0.03489f
C1115 DIV_ENABLE FS_LOW_N 0.03554f
C1116 HS_P_12 HS_PBIAS 4.10448f
C1117 HS_N_13 PULLDOWN_N_R 0.06832f
C1118 HS_P_11 HS_P_5 0.03881f
C1119 PULLUP_N_GATE DIFF_ENABLE 0.07144f
C1120 HS_P_1 PULLDOWN_P_R 0.08595f
C1121 HS_N_7 HS_N_9 0.04397f
C1122 PULLUP_P_CONTROL_S HS_N_5 0.04808f
C1123 TERM_GATE_N TERM_VCM 24.8972f
C1124 TERM_ENABLE FS_HIGH_N 0.05082f
C1125 HS_N_2 TERM_OR_N_S 0.02451f
C1126 FS_LOW_N DIFF_ENABLE 0.20718f
C1127 TERM_GATE_N PULLDOWN_P 0.15548f
C1128 HS_N_5 TERM_OR_P_B 0.07211f
C1129 TERM_GATE_N_BLEED_2 HS_N_11 0.02434f
C1130 TERM_GATE_P HS_N_8 0.12805f
C1131 TERM_GATE_N HS_N_10 0.04869f
C1132 HS_N_2 FS_LOW_N 0.08441f
C1133 FS_N_BLEED_0 FS_LOW_P 0.79203f
C1134 FS_N_BLEED_4 FS_N_BLEED_3 9.3821f
C1135 HS_N_3 FS_P_CONTROL_S 0.03226f
C1136 HS_N_13 PAD_P 0.08152f
C1137 HS_N_9 HS_P_3 0.03089f
C1138 HS_N HS_PBIAS 0.39831f
C1139 TERM_P_R HS_P_7 0.08343f
C1140 HS_N_2 FS_P_BLEED_3 0.02846f
C1141 TERM_P_R HS_P_12 0.11066f
C1142 HS_N_2 HS_P_1 0.09798f
C1143 HS_N_0 PAD_N 1.42664f
C1144 PULLUP_N PULLUP_N_BLEED_1 0.31155f
C1145 HS_P_6 HS_P_0 0.04603f
C1146 HS_N_9 HS_N_12 0.02504f
C1147 HS_P_1 HS_P_11 0.05935f
C1148 HS_P_8 HS_PBIAS 1.54227f
C1149 PULLUP_P_OUT VCM_LOW_OK 0.13743f
C1150 PULLUP_P_BLEED_3 PULLUP_P_BLEED_6 0
C1151 FS_N_OUT HS_P_6 0.06167f
C1152 FS_P_OUT VDD 10.8417f
C1153 PULLUP_N_OUT HS_PBIAS 0.76895f
C1154 TERM_GATE_P_BLEED_0 TERM_OR_P_B 0.0048f
C1155 PULLUP_P_BLEED_2 VCM_LOW_OK 0.15227f
C1156 HS_N_10 FS_P_CONTROL_S 0.03236f
C1157 TERM_GATE_N HS_N_8 0.05073f
C1158 FS_HIGH_N FS_N_WELL 2.50709f
C1159 HS_N_6 TERM_GATE_N_BLEED_1 0.0525f
C1160 HS_N_6 HS_P_0 0.03737f
C1161 FS_N_BLEED_4 FS_N_BLEED_5 0.79478f
C1162 FS_P_OUT HS_P_5 0.05462f
C1163 a_41005_132385# a_41005_132945# 0.0346f
C1164 TERM_P_R HS_N 0.11349f
C1165 HS_P_13 TERM_OR_P_NS 0.02895f
C1166 TERM_P_R HS_P_8 0.08296f
C1167 FS_P_BLEED_6 PULLDOWN_P_R 0.10124f
C1168 PULLUP_P_WELL FS_HIGH_P 0.27585f
C1169 DIV_N HS_N_5 0.03462f
C1170 TERM_ENABLE HS_PBIAS 0.73653f
C1171 FS_N_GATE FS_HIGH_P 0.13639f
C1172 PULLUP_N_OUT TERM_P_R 0.26239f
C1173 HS_N_7 HS_N_1 0.03096f
C1174 FS_P_BLEED_4 HS_N 0.08043f
C1175 HS_N_13 HS_N_4 0.14463f
C1176 PULLUP_P_OUT HS_P 0.03526f
C1177 HS_N_3 DIV_P 0.03388f
C1178 FS_P_CONTROL_S HS_N_8 0.03238f
C1179 PULLUP_P_WELL PULLDOWN_N_R 0.39593f
C1180 FS_N_GATE PULLDOWN_N_R 1.16382f
C1181 TERM_GATE_P_BLEED_2 TERM_GATE_P_BLEED_0 0.10759f
C1182 HS_N_13 PULLUP_P_BLEED_3 0.03489f
C1183 PULLUP_N_OUT FS_P_BLEED_4 0
C1184 TERM_N_R HS_P_10 0.05037f
C1185 TERM_GATE_N_BLEED_2 TERM_GATE_N 0.42751f
C1186 TERM_GATE_N_BLEED_0 TERM_GATE_N_BLEED_1 7.21575f
C1187 HS_N_3 PULLUP_P 0.02404f
C1188 TERM_OR_N_NS HS_PBIAS 0.04764f
C1189 TERM_GATE_P_BLEED_1 VDD 0.07121f
C1190 HS_P_3 HS_N_1 0.02599f
C1191 FS_N_BLEED_4 HS_N 0.06151f
C1192 DIV_LOW_N PULLUP_P 0.10124f
C1193 FS_P_BLEED_6 HS_N_2 0.06178f
C1194 TERM_VCM DIV_P 0.13218f
C1195 HS_N_13 HS_N_11 0.09269f
C1196 FS_N_OUT TERM_GATE_N_BLEED_0 0.06167f
C1197 HS_N_12 HS_N_1 0.03364f
C1198 TERM_P_R TERM_ENABLE 0.46656f
C1199 DIV_N PULLUP_P_BLEED_4 0
C1200 HS_P_13 PAD_N 0.16938f
C1201 FS_N_BLEED_4 PULLUP_N_OUT 0.05445f
C1202 TERM_VCM PULLUP_P 0.21883f
C1203 HS_N_10 PULLUP_P 0.02404f
C1204 HS_N_0 HS_PBIAS 7.78201f
C1205 PULLUP_P PULLDOWN_P 0.05412f
C1206 VDD HS_P_5 4.75167f
C1207 HS_P_6 PULLDOWN_P_R 0.02404f
C1208 FS_N_WELL HS_PBIAS 3.33611f
C1209 HS_N FS_P_BLEED_1 0.04405f
C1210 TERM_OR_N_NS TERM_P_R 0.21356f
C1211 PULLUP_N_BLEED_4 TERM_ENABLE 0.08954f
C1212 FS_P_WELL HS_PBIAS 3.47125f
C1213 TERM_N_R PULLUP_N_BLEED_5 0.11444f
C1214 HS_N_9 TERM_OR_P_NS 0.01002f
C1215 PULLUP_N_GATE VDD 11.92f
C1216 TERM_OR_N_S VDD 10.1707f
C1217 PULLUP_N_OUT FS_P_BLEED_1 0.06151f
C1218 FS_LOW_N VDD 2.24181f
C1219 FS_N_BLEED_4 TERM_ENABLE 0.06151f
C1220 HS_N_13 TERM_GATE_P 0.1076f
C1221 HS_N_2 HS_P_6 0.05876f
C1222 HS_N_0 TERM_P_R 0.10318f
C1223 PULLUP_P HS_N_8 0.02404f
C1224 HS_N_6 PULLDOWN_P_R 0.02404f
C1225 HS_P_11 HS_P_6 0.06713f
C1226 HS_P_1 VDD 5.54122f
C1227 HS_N_6 DIV_ENABLE 0.03089f
C1228 PULLUP_P_OUT FS_LOW_P 0.17673f
C1229 TERM_P_R FS_N_WELL 1.29698f
C1230 HS_N_7 HS_N_5 0.07689f
C1231 PULLDOWN_N_R FS_HIGH_P 0.04377f
C1232 FS_P_GATE HS_PBIAS 1.80592f
C1233 a_44789_117064# a_42245_90628# 11.6307f
C1234 PULLUP_P_WELL HS_N_4 0.12026f
C1235 FS_P_BLEED_4 HS_N_0 0.06178f
C1236 TERM_N_R TERM_OR_P_B 1.12426f
C1237 FS_P_WELL TERM_P_R 1.46056f
C1238 TERM_ENABLE FS_P_BLEED_1 0.05902f
C1239 PULLUP_P_GATE HS_N 0.13616f
C1240 HS_P_1 HS_P_5 0.02411f
C1241 TERM_OR_N_S FS_LOW_N 0.4405f
C1242 HS_N_9 PAD_N 1.0992f
C1243 PULLUP_N_GATE FS_LOW_N 0.17511f
C1244 HS_N_5 HS_P_3 0.03089f
C1245 PULLUP_P_WELL PULLUP_P_BLEED_3 0.00303f
C1246 HS_N_6 HS_N_2 0
C1247 PULLUP_P_BLEED_5 PULLDOWN_P_R 0.09218f
C1248 HS_N_6 HS_P_11 0.03089f
C1249 a_41005_131545# m2_42279_124800# 0.05457f
C1250 HS_P_2 HS_P_4 0.03986f
C1251 HS_N_13 TERM_GATE_N 0.04808f
C1252 PULLUP_N_OUT PULLUP_P_GATE 0.36087f
C1253 TERM_OR_P_S TERM_ENABLE 0.23041f
C1254 HS_N_12 HS_N_5 0
C1255 HS_N_7 TERM_GATE_P_BLEED_0 0
C1256 PULLUP_P_WELL HS_N_11 0.13224f
C1257 TERM_GATE_N_BLEED_0 DIV_ENABLE 0.01375f
C1258 FS_N_BLEED_4 FS_N_WELL 0.01068f
C1259 HS_N_7 PULLUP_P_BLEED_4 0.0525f
C1260 PULLUP_P_CONTROL_S BYPASS_ENABLE 0.00444f
C1261 FS_N_GATE HS_N_11 0.00893f
C1262 HS_P_13 HS_PBIAS 2.35188f
C1263 TERM_GATE_N_BLEED_2 PULLUP_P 0.09196f
C1264 FS_P_GATE TERM_P_R 0.79885f
C1265 PAD_P PULLDOWN_N_R 1.40429f
C1266 PULLUP_P_OUT FS_P_BLEED_2 0.00257f
C1267 TERM_VCM HS_P_2 0.09615f
C1268 HS_P_9 PULLDOWN_N_R 4.1634f
C1269 HS_N_2 PULLUP_P_BLEED_5 0.02404f
C1270 PULLUP_N_WELL TERM_VCM 0.36125f
C1271 HS_N_0 FS_P_BLEED_1 0.03472f
C1272 TERM_GATE_P_BLEED_0 HS_P_3 0.02464f
C1273 HS_N_2 TERM_GATE_N_BLEED_0 0.03489f
C1274 PULLUP_N_WELL PULLDOWN_P 0.47103f
C1275 FS_P_BLEED_4 FS_P_GATE 0.27551f
C1276 FS_P_OUT HS_P_6 0.15673f
C1277 TERM_N_R TERM_GATE_P_BLEED_2 0.8432f
C1278 VCM_LOW_OK HS_P_10 0.09044f
C1279 HS_N_13 FS_P_CONTROL_S 0.03226f
C1280 PULLUP_P_GATE TERM_ENABLE 0.84363f
C1281 FS_P_BLEED_6 VDD 0.01345f
C1282 DIV_N TERM_N_R 0.14748f
C1283 TERM_P_R HS_P_13 0.08554f
C1284 FS_P_WELL FS_P_BLEED_1 0.02734f
C1285 HS_N_12 PULLUP_P_BLEED_4 0.05263f
C1286 FS_N_BLEED_1 PULLUP_P 0.04819f
C1287 HS_P_7 HS_P_0 0.00469f
C1288 FS_P_BLEED_5 HS_P 0.06178f
C1289 PULLUP_P_BLEED_6 PULLUP_P 0.14694f
C1290 HS_P_12 HS_P_0 0.08899f
C1291 PAD_P HS_P_9 1.35439f
C1292 HS_N_6 FS_P_OUT 0.43331f
C1293 HS_P_2 HS_N_8 0.02404f
C1294 FS_N_OUT HS_P_12 0.12335f
C1295 HS_N_4 FS_HIGH_P 0.02404f
C1296 PAD_N HS_N_1 1.13339f
C1297 PULLDOWN_N PULLDOWN_N_R 2.99559f
C1298 PULLUP_P_BLEED_3 FS_HIGH_P 0.166f
C1299 HS_N_4 PULLDOWN_N_R 0.06159f
C1300 HS_N_9 HS_PBIAS 1.96438f
C1301 HS_P HS_P_10 2.44809f
C1302 FS_P_GATE FS_P_BLEED_1 0.17756f
C1303 FS_N_BLEED_0 PULLDOWN_P 0.07407f
C1304 PULLUP_P_GATE HS_N_0 0.08394f
C1305 DIV_N BYPASS_ENABLE 0.09436f
C1306 TERM_GATE_N_BLEED_1 HS_N 0.10264f
C1307 HS_N_11 FS_HIGH_P 0.02435f
C1308 PULLUP_P_BLEED_3 PULLDOWN_N_R 0.05462f
C1309 HS_N HS_P_0 0.54906f
C1310 VDD HS_P_6 6.8233f
C1311 FS_N_OUT HS_N 1.15664f
C1312 FS_P_BLEED_6 FS_P_BLEED_3 0.12236f
C1313 PULLUP_N_OUT TERM_GATE_N_BLEED_1 0.09196f
C1314 HS_N_11 PULLDOWN_N_R 0.06159f
C1315 PULLUP_N_OUT HS_P_0 0.09237f
C1316 HS_N_4 PAD_P 0.06517f
C1317 HS_N_5 TERM_OR_P_NS 0.00258f
C1318 FS_N_OUT PULLUP_N_OUT 0.50078f
C1319 HS_N_13 PULLUP_P 0.07466f
C1320 VCM_LOW_OK TERM_OR_P_B 2.10826f
C1321 HS_P_6 HS_P_5 32.3343f
C1322 VDD FS_N_BLEED_2 0.01834f
C1323 HS_N_9 TERM_P_R 0.0592f
C1324 PULLUP_N_BLEED_6 FS_HIGH_P 0.08992f
C1325 HS_N_6 VDD 6.90044f
C1326 HS_N_11 PAD_P 0.38848f
C1327 PULLUP_P_BLEED_1 VDD 0.07323f
C1328 PULLUP_P_GATE FS_P_GATE 0.53486f
C1329 TERM_GATE_N_BLEED_1 TERM_ENABLE 0.07928f
C1330 HS_N_9 FS_P_BLEED_4 0.06295f
C1331 PULLUP_N_BLEED_6 PULLDOWN_N_R 0.04864f
C1332 TERM_ENABLE HS_P_0 0.03037f
C1333 HS_N_7 TERM_N_R 0.11615f
C1334 HS_N_6 HS_P_5 0.1437f
C1335 DIV_ENABLE FS_N_BLEED_5 0
C1336 FS_N_OUT TERM_ENABLE 0.47587f
C1337 TERM_GATE_P PULLDOWN_N_R 0.26213f
C1338 HS_P_12 PULLDOWN_P_R 0.02404f
C1339 HS_P_7 PULLDOWN_P_R 0.02411f
C1340 HS_P_1 HS_P_6 0.06271f
C1341 PULLUP_P_CONTROL_S HS_P 0.04808f
C1342 PAD_N HS_N_5 1.1645f
C1343 HS_N_1 HS_PBIAS 2.51285f
C1344 HS_P TERM_OR_P_B 0.0917f
C1345 HS_N_6 TERM_OR_N_S 0.02755f
C1346 PULLUP_N_WELL FS_N_BLEED_1 0
C1347 FS_LOW_N FS_N_BLEED_2 0
C1348 FS_LOW_P HS_P_10 0.05509f
C1349 TERM_N_R HS_P_3 0.05037f
C1350 PULLUP_P_OUT FS_P_BLEED_0 0.11038f
C1351 VCM_LOW_OK TERM_GATE_P_BLEED_2 0.01429f
C1352 FS_N_OUT TERM_OR_N_NS 0.06103f
C1353 TERM_GATE_N_BLEED_0 VDD 0.45815f
C1354 HS_N_6 FS_LOW_N 0.08478f
C1355 TERM_N_R HS_N_12 0.0597f
C1356 TERM_GATE_N FS_HIGH_P 0.00415f
C1357 BYPASS_ENABLE RX_P 4.97887f
C1358 TERM_GATE_N_BLEED_1 HS_N_0 0.05293f
C1359 DIV_N VCM_LOW_OK 0.00178f
C1360 PULLUP_P_BLEED_3 HS_N_4 0.03489f
C1361 HS_N_6 HS_P_1 0.03099f
C1362 HS_N_6 FS_P_BLEED_3 0.03529f
C1363 HS_N_2 HS_P_12 0.06578f
C1364 HS_N_0 HS_P_0 0.04061f
C1365 FS_P_BLEED_5 FS_P_BLEED_2 0.12885f
C1366 HS_N_9 FS_P_BLEED_1 0.03472f
C1367 HS_P_11 HS_P_7 0.0963f
C1368 PULLUP_N_BLEED_3 PULLDOWN_P 0.00326f
C1369 FS_N_CONTROL_S HS_N 0.12118f
C1370 HS_N PULLDOWN_P_R 0.04388f
C1371 TERM_GATE_P HS_P_9 0.22051f
C1372 HS_P_12 HS_P_11 46.9655f
C1373 TERM_GATE_N PULLDOWN_N_R 0.12021f
C1374 HS_N_4 HS_N_11 0
C1375 HS_N DIV_ENABLE 0.05802f
C1376 FS_N_OUT HS_N_0 0.06167f
C1377 HS_P_8 PULLDOWN_P_R 0.08554f
C1378 TERM_P_R HS_N_1 0.06087f
C1379 PULLUP_N_OUT FS_N_CONTROL_S 0.10706f
C1380 TERM_GATE_N_BLEED_0 TERM_OR_N_S 0
C1381 PULLUP_N_OUT PULLDOWN_P_R 0.10143f
C1382 FS_N_OUT FS_N_WELL 0.1934p
C1383 PULLUP_P_BLEED_3 HS_N_11 0.03489f
C1384 PULLUP_P_OUT HS_P_4 0.05519f
C1385 PULLUP_P_BLEED_5 FS_LOW_N 0.02437f
C1386 PULLUP_P_WELL PULLUP_P 0.15487f
C1387 TERM_OR_N_B HS_PBIAS 0.01781f
C1388 RX_N PAD_P 0.47227f
C1389 PULLUP_N_OUT DIV_ENABLE 0.05062f
C1390 FS_N_GATE PULLUP_P 1.02581f
C1391 TERM_GATE_N_BLEED_0 FS_LOW_N 0.07127f
C1392 HS_N DIFF_ENABLE 0.3376f
C1393 PULLUP_P_OUT HS_N_3 0.03489f
C1394 FS_P_CONTROL_S FS_HIGH_P 0.51548f
C1395 FS_N_BLEED_0 FS_N_BLEED_1 4.78029f
C1396 FS_N_OUT FS_P_WELL 0.93211f
C1397 FS_P_BLEED_4 HS_N_1 0.06178f
C1398 HS_N_2 HS_N 6.83901f
C1399 HS_N HS_P_11 0.6688f
C1400 PULLUP_N_BLEED_6 PULLDOWN_N 0
C1401 DIV_N HS_P 0.03732f
C1402 HS_P_11 HS_P_8 0.00792f
C1403 PULLUP_N_OUT HS_P_11 0.08824f
C1404 PULLUP_P_OUT TERM_VCM 0.36501f
C1405 TERM_ENABLE PULLDOWN_P_R 0.08114f
C1406 HS_N_4 TERM_GATE_P 0.11218f
C1407 PULLUP_P_CONTROL_S FS_LOW_P 0.05888f
C1408 PULLUP_P_OUT HS_N_10 0.03489f
C1409 HS_N_9 PULLUP_P_GATE 0.08704f
C1410 FS_N_CONTROL_S TERM_ENABLE 0.12118f
C1411 PULLUP_P_BLEED_2 TERM_VCM 0.08967f
C1412 FS_N_OUT FS_P_GATE 0.35576f
C1413 DIV_N DIV_LOW_P 0.89345f
C1414 TERM_ENABLE DIV_ENABLE 0.05768f
C1415 FS_LOW_P TERM_OR_P_B 1.1369f
C1416 TERM_OR_N_B TERM_P_R 0.37734f
C1417 HS_N_5 HS_PBIAS 4.87448f
C1418 FS_N_BLEED_6 HS_P 0.11073f
C1419 FS_P_OUT HS_P_12 0.10923f
C1420 FS_P_BLEED_6 HS_N_6 0.06178f
C1421 TERM_ENABLE DIFF_ENABLE 0.17128f
C1422 FS_P_BLEED_1 HS_N_1 0.03472f
C1423 HS_N_11 TERM_GATE_P 0.10852f
C1424 HS_N_2 TERM_ENABLE 0.04808f
C1425 FS_N_BLEED_3 VDD 0.5567f
C1426 TERM_ENABLE HS_P_11 0.07923f
C1427 HS_P_13 HS_P_0 0.01899f
C1428 HS_N_7 VCM_LOW_OK 0.05893f
C1429 PULLUP_P_OUT HS_N_8 0.0351f
C1430 TERM_GATE_N HS_N_4 0.04808f
C1431 a_53878_133225# a_53878_133785# 0.0346f
C1432 HS_N_0 PULLDOWN_P_R 0.02508f
C1433 TERM_N_R TERM_OR_P_NS 0.1011f
C1434 TERM_P_R HS_N_5 0.05893f
C1435 PULLUP_N PULLDOWN_P 5.21685f
C1436 PULLUP_P_BLEED_4 HS_PBIAS 0.07928f
C1437 HS_N_2 TERM_OR_N_NS 0.03425f
C1438 FS_P_OUT HS_N 20.4712f
C1439 HS_N_0 DIV_ENABLE 2.34864f
C1440 PULLUP_P FS_HIGH_P 0.06616f
C1441 FS_N_CONTROL_S FS_N_WELL 0.9381f
C1442 DIV_P PULLDOWN_N_R 0.01299f
C1443 a_53878_133225# ESD_RAIL 0.53916f
C1444 DIV_ENABLE FS_N_WELL 0.23482f
C1445 a_41005_132945# a_41005_133505# 0.0346f
C1446 VCM_LOW_OK HS_P_3 0.09096f
C1447 FS_N_BLEED_3 PULLUP_N_GATE 0
C1448 FS_P_WELL PULLDOWN_P_R 3.25452f
C1449 PULLUP_P PULLDOWN_N_R 0.04377f
C1450 PULLUP_N_OUT FS_P_OUT 0.573f
C1451 TERM_GATE_N HS_N_11 0.04856f
C1452 FS_P_BLEED_4 HS_N_5 0.06219f
C1453 VDD FS_N_BLEED_5 0.00257f
C1454 FS_P_WELL DIV_ENABLE 0.08405f
C1455 DIV_N FS_LOW_P 6.0078f
C1456 HS_N_6 HS_P_6 0.06938f
C1457 HS_N_2 HS_N_0 0.04171f
C1458 HS_N_12 VCM_LOW_OK 0.05893f
C1459 FS_N_BLEED_3 FS_LOW_N 0
C1460 PULLUP_P_GATE HS_N_1 0.08375f
C1461 HS_N_4 FS_P_CONTROL_S 0.03226f
C1462 VDD HS_P_7 4.96081f
C1463 HS_N_7 HS_P 0.33704f
C1464 HS_P_12 VDD 4.78775f
C1465 PAD_P DIV_P 2.52939f
C1466 TERM_P_R TERM_GATE_P_BLEED_0 0.00257f
C1467 ESD_RAIL m2_42279_124800# 5.47988f
C1468 TERM_N_R PAD_N 0.56726f
C1469 HS_N_2 FS_P_WELL 1.96621f
C1470 FS_P_GATE PULLDOWN_P_R 1.57717f
C1471 HS_P_7 HS_P_5 0.03078f
C1472 FS_N_BLEED_6 FS_LOW_P 0.05624f
C1473 HS_N_9 HS_P_0 0.03791f
C1474 HS_N_9 TERM_GATE_N_BLEED_1 0.0525f
C1475 HS_P_12 HS_P_5 0.03887f
C1476 HS_P HS_P_3 1.89056f
C1477 FS_P_GATE DIV_ENABLE 0.00424f
C1478 FS_P_OUT TERM_ENABLE 0.53051f
C1479 PULLUP_N_GATE FS_N_BLEED_5 0
C1480 HS_N_11 FS_P_CONTROL_S 0.03234f
C1481 TERM_N_R FS_HIGH_N 0.05037f
C1482 FS_LOW_N FS_N_BLEED_5 0.084f
C1483 HS_N VDD 2.60831f
C1484 HS_N_5 FS_P_BLEED_1 0.03472f
C1485 DIV_N FS_P_BLEED_2 0
C1486 HS_N_12 HS_P 0.78589f
C1487 PULLUP_N_CONTROL_S PULLUP_P 0.09193f
C1488 VDD HS_P_8 4.99906f
C1489 PULLUP_N_OUT TERM_GATE_P_BLEED_1 0.05318f
C1490 HS_N_2 FS_P_GATE 1.03585f
C1491 PAD_N BYPASS_ENABLE 11.6747f
C1492 PULLUP_N_OUT VDD 5.43573f
C1493 HS_P_13 PULLDOWN_P_R 0.02404f
C1494 FS_N_GATE FS_N_BLEED_0 0.40602f
C1495 HS_N HS_P_5 0.39228f
C1496 HS_P_1 HS_P_7 0.05962f
C1497 HS_N_12 DIV_LOW_P 0.00136f
C1498 HS_N_6 PULLUP_P_BLEED_5 0.03334f
C1499 HS_P_12 HS_P_1 0.05935f
C1500 FS_P_BLEED_5 HS_N_3 0.06178f
C1501 BYPASS_ENABLE FS_HIGH_N 0
C1502 HS_P_8 HS_P_5 0.00106f
C1503 HS_N_6 TERM_GATE_N_BLEED_0 0.03489f
C1504 HS_N TERM_OR_N_S 0.07589f
C1505 FS_P_OUT HS_N_0 0.5609f
C1506 PULLUP_N_GATE HS_N 0.16548f
C1507 PULLUP_N_OUT HS_P_5 0.02859f
C1508 HS_N_4 PULLUP_P 0.02473f
C1509 PULLUP_N_WELL FS_HIGH_P 0.30751f
C1510 TERM_ENABLE TERM_GATE_P_BLEED_1 0.10319f
C1511 HS_N FS_LOW_N 0.11362f
C1512 HS_P_4 HS_P_10 0
C1513 HS_N_2 HS_P_13 0.07762f
C1514 PULLUP_N_OUT PULLUP_N_GATE 16.6062f
C1515 PULLUP_N_OUT TERM_OR_N_S 0.13603f
C1516 HS_P_2 PULLDOWN_N_R 0.07217f
C1517 FS_P_WELL FS_P_OUT 0.18171p
C1518 PAD_N ESD_RAIL 22.6825f
C1519 FS_P_BLEED_5 HS_N_10 0.06178f
C1520 PULLUP_P_GATE HS_N_5 0.08413f
C1521 TERM_ENABLE VDD 12.7935f
C1522 HS_N_7 FS_LOW_P 0.0855f
C1523 HS_P_13 HS_P_11 0.08851f
C1524 FS_P_BLEED_3 HS_N 0.0463f
C1525 PULLUP_P_BLEED_3 PULLUP_P 0.27184f
C1526 PULLUP_N_WELL PULLDOWN_N_R 0.304f
C1527 HS_N HS_P_1 0.75007f
C1528 PULLUP_N_OUT FS_LOW_N 0.06432f
C1529 HS_N_1 HS_P_0 0.04113f
C1530 TERM_GATE_N_BLEED_1 HS_N_1 0.05286f
C1531 VCM_LOW_OK TERM_OR_P_NS 2.92628f
C1532 TERM_N_R HS_PBIAS 0.70629f
C1533 HS_P_1 HS_P_8 0.02404f
C1534 HS_N_11 PULLUP_P 0.02473f
C1535 TERM_OR_N_NS VDD 0.44386f
C1536 PULLUP_N_OUT HS_P_1 0.05947f
C1537 TERM_ENABLE HS_P_5 0.02404f
C1538 PULLUP_P_OUT HS_N_13 0.03489f
C1539 FS_N_OUT HS_N_1 0.06167f
C1540 TERM_VCM HS_P_10 0.13491f
C1541 FS_LOW_P HS_P_3 0.04607f
C1542 HS_N_10 HS_P_10 0.09288f
C1543 FS_P_OUT FS_P_GATE 0.13406p
C1544 PAD_P HS_P_2 1.20139f
C1545 TERM_OR_N_S TERM_ENABLE 5.34861f
C1546 HS_N_9 PULLDOWN_P_R 0.02404f
C1547 PULLUP_N_GATE TERM_ENABLE 0.24055f
C1548 HS_N_12 FS_LOW_P 0.08505f
C1549 FS_P_BLEED_5 HS_N_8 0.06178f
C1550 HS_P_2 HS_P_9 0.0419f
C1551 HS_N_9 DIV_ENABLE 0.03089f
C1552 PULLUP_P_GATE PULLUP_P_BLEED_4 0.10639f
C1553 FS_N_BLEED_0 FS_HIGH_P 0.00106f
C1554 HS_N_0 VDD 4.91768f
C1555 TERM_ENABLE FS_LOW_N 0.37409f
C1556 PULLUP_N_BLEED_0 PULLUP_N_BLEED_1 3.40429f
C1557 VDD FS_N_WELL 0.10242p
C1558 TERM_GATE_P DIV_P 0.02274f
C1559 TERM_N_R TERM_P_R 28.0337f
C1560 PULLUP_N_BLEED_6 PULLUP_P 0.05764f
C1561 TERM_OR_N_NS TERM_OR_N_S 0.00164f
C1562 TERM_ENABLE HS_P_1 0.02404f
C1563 HS_P TERM_OR_P_NS 0.04056f
C1564 FS_N_BLEED_0 PULLDOWN_N_R 0.05188f
C1565 PULLUP_N_WELL PULLUP_N_CONTROL_S 0.11761f
C1566 FS_P_WELL VDD 99.794f
C1567 a_53878_132665# a_53878_133225# 0.0346f
C1568 HS_N_2 HS_N_9 0
C1569 HS_N_8 HS_P_10 0.0286f
C1570 TERM_OR_N_NS FS_LOW_N 3.61751f
C1571 HS_N_0 HS_P_5 0.03489f
C1572 TERM_VCM PULLUP_N_BLEED_5 0.13759f
C1573 FS_P_OUT HS_P_13 0.1275f
C1574 FS_N_BLEED_3 FS_N_BLEED_2 7.86857f
C1575 HS_N_9 HS_P_11 0.03103f
C1576 PULLDOWN_P PULLUP_N_BLEED_5 0
C1577 PULLUP_P_CONTROL_S HS_N_3 0.04808f
C1578 TERM_OR_P_B HS_P_4 0.10189f
C1579 PULLUP_N_BLEED_4 TERM_N_R 0.05729f
C1580 HS_N_0 TERM_OR_N_S 0.02686f
C1581 a_53878_132105# ESD_RAIL 0.53942f
C1582 HS_N_3 TERM_OR_P_B 0.07211f
C1583 FS_P_BLEED_2 HS_N_12 0
C1584 FS_P_BLEED_6 HS_N 0.08043f
C1585 RX_N DIV_P 0.37599f
C1586 HS_N_4 HS_P_2 0.00376f
C1587 HS_N_0 FS_LOW_N 0.08452f
C1588 FS_P_GATE VDD 26.6621f
C1589 PULLUP_N_BLEED_1 HS_PBIAS 0.17672f
C1590 FS_N_BLEED_4 TERM_N_R 0.06105f
C1591 FS_P_BLEED_6 PULLUP_N_OUT 0.11535f
C1592 HS_P_7 HS_P_6 31.6746f
C1593 FS_LOW_N FS_N_WELL 0.90409f
C1594 PULLUP_P_CONTROL_S HS_N_10 0.04949f
C1595 FS_P_BLEED_3 HS_N_0 0.02973f
C1596 HS_P_12 HS_P_6 0.07018f
C1597 TERM_GATE_N_BLEED_1 HS_N_5 0.0525f
C1598 TERM_VCM TERM_OR_P_B 0.06482f
C1599 PAD_N HS_P 1.82419f
C1600 PULLUP_N_BLEED_2 PULLUP_N_BLEED_1 1.89414f
C1601 HS_N_10 TERM_OR_P_B 0.0738f
C1602 HS_N_5 HS_P_0 0.03733f
C1603 TERM_GATE_N PULLUP_P 0.21883f
C1604 PULLDOWN_P_R HS_N_1 0.02445f
C1605 PULLUP_P_OUT PULLUP_P_WELL 29.1254f
C1606 HS_P FS_HIGH_N 0.03743f
C1607 TERM_N_R FS_P_BLEED_1 0.06105f
C1608 DIV_ENABLE HS_N_1 0.03212f
C1609 PULLUP_P_BLEED_2 PULLUP_P_WELL 0
C1610 FS_N_BLEED_4 BYPASS_ENABLE 0.00766f
C1611 HS_N_6 HS_P_12 0.06578f
C1612 HS_P_13 VDD 6.64318f
C1613 HS_N HS_P_6 0.5265f
C1614 HS_N_9 FS_P_OUT 0.43377f
C1615 FS_P_BLEED_6 TERM_ENABLE 0.08457f
C1616 TERM_GATE_P_BLEED_0 HS_P_0 0.00591f
C1617 PULLUP_P_CONTROL_S HS_N_8 0.04808f
C1618 FS_LOW_P TERM_OR_P_NS 0.39723f
C1619 TERM_N_R TERM_OR_P_S 0.0546f
C1620 HS_N_2 HS_N_1 0.00962f
C1621 TERM_OR_P_B HS_N_8 0.07245f
C1622 HS_P_11 HS_N_1 0.02846f
C1623 HS_P_8 HS_P_6 0.00206f
C1624 DIV_N HS_N_3 0.03505f
C1625 FS_P_BLEED_3 FS_P_GATE 0.27756f
C1626 HS_P_13 HS_P_5 0.26928f
C1627 VCM_LOW_OK HS_PBIAS 0.42204f
C1628 PULLUP_N_OUT HS_P_6 0.02846f
C1629 PULLUP_N_BLEED_0 HS_P 0.07928f
C1630 BYPASS_ENABLE FS_P_BLEED_1 0.00766f
C1631 DIV_N DIV_LOW_N 6.86692f
C1632 FS_N_OUT PULLUP_P_BLEED_4 0.06408f
C1633 HS_N FS_N_BLEED_2 0.11535f
C1634 TERM_VCM TERM_GATE_P_BLEED_2 0.02194f
C1635 PULLUP_N_WELL PULLUP_N_BLEED_6 0.00637f
C1636 PULLUP_N_BLEED_3 PULLDOWN_N_R 0.00237f
C1637 TERM_GATE_P HS_P_2 0.15718f
C1638 HS_N_6 HS_N 7.99416f
C1639 DIV_N TERM_VCM 0.67599f
C1640 PULLUP_N_OUT FS_N_BLEED_2 0.10124f
C1641 TERM_N_R PULLUP_P_GATE 0.16992f
C1642 DIV_N PULLDOWN_P 0.0465f
C1643 DIV_N HS_N_10 0.03462f
C1644 HS_N_6 PULLUP_N_OUT 0.05599f
C1645 FS_P_BLEED_6 HS_N_0 0.06178f
C1646 PULLUP_N_OUT PULLUP_P_BLEED_1 0
C1647 TERM_ENABLE HS_P_6 0.02404f
C1648 VCM_LOW_OK TERM_P_R 0.39366f
C1649 HS_P_13 HS_P_1 0.11352f
C1650 HS_N_13 FS_P_BLEED_5 0.06178f
C1651 HS_P HS_PBIAS 0.16546p
C1652 PULLUP_P_OUT FS_HIGH_P 0.10214f
C1653 HS_N_9 VDD 5.99389f
C1654 PULLUP_P_BLEED_5 HS_N 0.05048f
C1655 HS_N_7 FS_P_BLEED_0 0.06178f
C1656 HS_N_5 PULLDOWN_P_R 0.02404f
C1657 TERM_GATE_N_BLEED_0 HS_N 0.04828f
C1658 TERM_ENABLE FS_N_BLEED_2 0.08954f
C1659 FS_LOW_P FS_HIGH_N 0.11423f
C1660 HS_N_5 DIV_ENABLE 0.03089f
C1661 DIV_N HS_N_8 0.03462f
C1662 PULLUP_P_OUT PULLDOWN_N_R 0.10342f
C1663 PULLUP_N_BLEED_2 HS_P 0.00212f
C1664 PULLUP_N_OUT PULLUP_P_BLEED_5 0.09196f
C1665 DIV_LOW_P HS_PBIAS 0
C1666 FS_P_OUT HS_N_1 0.44686f
C1667 HS_N_6 TERM_ENABLE 0.10332f
C1668 HS_N_9 HS_P_5 0.06578f
C1669 TERM_GATE_N_BLEED_0 PULLUP_N_OUT 0.05462f
C1670 PULLUP_P_BLEED_1 TERM_ENABLE 0.07608f
C1671 FS_P_BLEED_6 FS_P_GATE 6.82321f
C1672 HS_N_9 TERM_OR_N_S 0.03405f
C1673 HS_N_12 FS_P_BLEED_0 0.06178f
C1674 HS_N_0 HS_P_6 0.06114f
C1675 TERM_P_R HS_P 0.07234f
C1676 HS_N_2 HS_N_5 0.00106f
C1677 HS_N_6 TERM_OR_N_NS 0.03425f
C1678 HS_N_5 HS_P_11 0.03089f
C1679 PULLUP_N_BLEED_0 FS_LOW_P 0.05872f
C1680 TERM_GATE_P_BLEED_0 PULLDOWN_P_R 0.12409f
C1681 HS_N_7 HS_N_3 0.06865f
C1682 PULLUP_P_BLEED_4 PULLDOWN_P_R 0.09196f
C1683 HS_N_9 FS_LOW_N 0.08512f
C1684 PULLUP_P_OUT PAD_P 0.43807f
C1685 HS_N_7 DIV_LOW_N 0.06178f
C1686 PULLUP_P_BLEED_4 DIV_ENABLE 0
C1687 TERM_P_R DIV_LOW_P 0.00106f
C1688 PULLUP_P_BLEED_5 TERM_ENABLE 0
C1689 FS_P_BLEED_4 HS_P 0.06337f
C1690 a_53878_132105# a_53878_132665# 0.0346f
C1691 HS_N_9 FS_P_BLEED_3 0.04642f
C1692 VCM_LOW_OK FS_P_BLEED_1 0.0381f
C1693 PULLUP_P_OUT HS_P_9 0.06897f
C1694 FS_N_BLEED_2 FS_N_WELL 0.35588f
C1695 HS_N_9 HS_P_1 0.0312f
C1696 TERM_GATE_N_BLEED_0 TERM_ENABLE 0.04931f
C1697 PULLUP_N PULLDOWN_N_R 0.00106f
C1698 HS_P_3 HS_P_4 33.6448f
C1699 HS_N_6 HS_N_0 0.04157f
C1700 FS_N_BLEED_3 FS_N_BLEED_5 0
C1701 HS_N_7 TERM_VCM 0.16639f
C1702 HS_N_3 HS_P_3 0.03733f
C1703 HS_N_7 HS_N_10 0.03027f
C1704 PULLUP_P_BLEED_5 TERM_OR_N_NS 0
C1705 HS_N_7 PULLDOWN_P 0.04428f
C1706 HS_N_2 PULLUP_P_BLEED_4 0.0525f
C1707 TERM_N_R TERM_GATE_N_BLEED_1 0.07874f
C1708 FS_N_BLEED_4 HS_P 0.04811f
C1709 TERM_GATE_P_BLEED_0 HS_P_11 0.03689f
C1710 FS_LOW_P HS_PBIAS 0.34356f
C1711 HS_N_12 HS_N_3 0.03984f
C1712 TERM_OR_P_S VCM_LOW_OK 1.87902f
C1713 VDD HS_N_1 4.91737f
C1714 HS_N_6 FS_P_WELL 1.97843f
C1715 FS_N_OUT TERM_N_R 0.38856f
C1716 FS_P_BLEED_5 PULLUP_P_WELL 0.00636f
C1717 DIV_LOW_N HS_N_12 0.06178f
C1718 HS_N_10 HS_P_3 0.02545f
C1719 TERM_VCM HS_P_3 0.12019f
C1720 HS_N_13 PULLUP_P_CONTROL_S 0.04867f
C1721 PULLUP_P_BLEED_5 HS_N_0 0.02492f
C1722 HS_N_13 TERM_OR_P_B 0.07271f
C1723 HS_N_12 TERM_VCM 0.12019f
C1724 HS_P FS_P_BLEED_1 0.03472f
C1725 HS_N_1 HS_P_5 0.03489f
C1726 HS_N_12 PULLDOWN_P 0.04428f
C1727 TERM_GATE_N_BLEED_0 HS_N_0 0.03489f
C1728 HS_N_12 HS_N_10 0.07075f
C1729 PULLUP_P_OUT HS_N_4 0.03489f
C1730 PULLUP_P_GATE VCM_LOW_OK 0.22296f
C1731 FS_P_OUT HS_N_5 0.43331f
C1732 HS_N_7 HS_N_8 0.11965p
C1733 FS_N_BLEED_3 HS_N 0.11535f
C1734 HS_N_6 FS_P_GATE 1.04254f
C1735 TERM_OR_N_S HS_N_1 0.02599f
C1736 PULLUP_N_CONTROL_S PULLUP_N 1.30292f
C1737 PULLUP_N_BLEED_3 PULLUP_N_BLEED_6 0.0078f
C1738 TERM_P_R FS_LOW_P 0.15007f
C1739 HS_P_13 HS_P_6 0.15959f
C1740 HS_P_12 HS_P_7 0.11376f
C1741 FS_N_BLEED_3 PULLUP_N_OUT 0.10124f
C1742 a_53878_132105# a_53878_131545# 0.0346f
C1743 FS_LOW_N HS_N_1 0.12614f
C1744 PULLUP_N_WELL PULLUP_P 9.02284f
C1745 PULLUP_P_BLEED_2 PULLUP_P_BLEED_3 3.88784f
C1746 TERM_OR_N_B VDD 10.4444f
C1747 PULLUP_P_OUT HS_N_11 0.03489f
C1748 HS_P_3 HS_N_8 0.02404f
C1749 FS_P_BLEED_6 HS_N_9 0.06178f
C1750 HS_P_1 HS_N_1 0.09066f
C1751 FS_P_BLEED_3 HS_N_1 0.02938f
C1752 HS_N_12 HS_N_8 0.03497f
C1753 HS_N_6 HS_P_13 0.05493f
C1754 HS_N FS_N_BLEED_5 0.02443f
C1755 PULLUP_N PULLDOWN_N 0
C1756 PULLUP_P_GATE HS_P 0.08871f
C1757 HS_N_7 TERM_GATE_N_BLEED_2 0.03702f
C1758 HS_N HS_P_7 0.15132f
C1759 FS_N_BLEED_4 FS_LOW_P 0.23267f
C1760 PULLUP_P_WELL PULLUP_P_BLEED_0 1.08596f
C1761 HS_P_12 HS_N 0.5567f
C1762 FS_N_BLEED_3 TERM_ENABLE 0.11535f
C1763 DIV_N HS_N_13 0.03462f
C1764 TERM_OR_N_B TERM_OR_N_S 4.08319f
C1765 HS_P_12 HS_P_8 0
C1766 HS_P_8 HS_P_7 30.9838f
C1767 HS_N_5 VDD 6.46267f
C1768 PULLUP_N_OUT HS_P_7 0.02846f
C1769 TERM_N_R FS_N_CONTROL_S 0.12536f
C1770 PULLUP_P_OUT TERM_GATE_P 0.40537f
C1771 PULLUP_N_OUT HS_P_12 0.03006f
C1772 a_41005_131825# m2_42279_124800# 0
C1773 TERM_OR_N_B FS_LOW_N 2.73977f
C1774 TERM_OR_P_NS HS_P_4 0.02846f
C1775 FS_P_BLEED_5 PULLDOWN_N_R 0.10378f
C1776 TERM_N_R DIV_ENABLE 0.09755f
C1777 FS_LOW_P FS_P_BLEED_1 0.07139f
C1778 PULLUP_P_CONTROL_S PULLUP_P_WELL 0.02696f
C1779 FS_P_BLEED_2 FS_P_BLEED_4 0.12224f
C1780 HS_N_3 TERM_OR_P_NS 0.00153f
C1781 HS_N_5 HS_P_5 0.10295f
C1782 HS_N_9 HS_P_6 0.05493f
C1783 TERM_GATE_N_BLEED_2 HS_N_12 0.02427f
C1784 TERM_N_R DIFF_ENABLE 6.47766f
C1785 HS_N_7 PULLUP_P_BLEED_6 0
C1786 TERM_GATE_P_BLEED_1 TERM_GATE_P_BLEED_0 2.63577f
C1787 HS_N HS_P_8 0.19016f
C1788 TERM_GATE_P_BLEED_0 VDD 0.12131f
C1789 PULLDOWN_N_R HS_P_10 0.07466f
C1790 HS_N_2 TERM_N_R 0.0594f
C1791 TERM_OR_N_S HS_N_5 0.02662f
C1792 PULLUP_N_OUT HS_N 0.10855f
C1793 TERM_OR_P_S FS_LOW_P 0.36544f
C1794 TERM_N_R HS_P_11 0.05722f
C1795 TERM_ENABLE HS_P_7 0.02404f
C1796 TERM_VCM TERM_OR_P_NS 0.00155f
C1797 HS_P_12 TERM_ENABLE 0.02404f
C1798 VCM_LOW_OK HS_P_0 0.04122f
C1799 FS_N_BLEED_3 FS_N_WELL 0.1181f
C1800 FS_P_BLEED_6 HS_N_1 0.06178f
C1801 HS_N_5 FS_LOW_N 0.08469f
C1802 BYPASS_ENABLE DIV_ENABLE 75.0001f
C1803 PULLUP_N_BLEED_6 PULLUP_N 0.17333f
C1804 PULLUP_N_OUT HS_P_8 0.0429f
C1805 FS_N_OUT VCM_LOW_OK 0.1125f
C1806 HS_N_6 HS_N_9 0.04101f
C1807 PAD_N HS_P_4 0.27735f
C1808 TERM_GATE_P_BLEED_0 HS_P_5 0.0244f
C1809 HS_N_5 HS_P_1 0.03097f
C1810 FS_P_BLEED_3 HS_N_5 0.03351f
C1811 HS_N_3 PAD_N 1.66755f
C1812 BYPASS_ENABLE DIFF_ENABLE 5.18795f
C1813 FS_P_BLEED_2 FS_P_BLEED_1 1.41312f
C1814 PAD_P HS_P_10 1.26307f
C1815 PULLUP_P_GATE FS_LOW_P 0.15193f
C1816 HS_N TERM_ENABLE 0.07737f
C1817 HS_P_9 HS_P_10 0.00887f
C1818 TERM_OR_P_NS HS_N_8 0.00704f
C1819 TERM_ENABLE HS_P_8 0.02404f
C1820 HS_N_9 PULLUP_P_BLEED_5 0.04943f
C1821 TERM_GATE_N_BLEED_1 HS_P 0.0525f
C1822 PAD_N TERM_VCM 0.001f
C1823 PULLUP_P_BLEED_0 PULLDOWN_N_R 0.00171f
C1824 HS_N_10 PAD_N 1.35483f
C1825 HS_N_9 TERM_GATE_N_BLEED_0 0.03489f
C1826 HS_N_7 HS_N_13 0.09546f
C1827 HS_N_0 HS_P_12 0.07547f
C1828 PULLUP_P_BLEED_4 FS_LOW_N 0.02437f
C1829 HS_P HS_P_0 17.7665f
C1830 DIV_N PULLUP_P_WELL 0.08038f
C1831 PULLUP_N_OUT TERM_ENABLE 0.19202f
C1832 TERM_GATE_P_BLEED_0 HS_P_1 0.05525f
C1833 FS_N_OUT HS_P 0.77167f
C1834 TERM_OR_N_NS HS_N 0.04764f
C1835 PULLUP_P_CONTROL_S FS_HIGH_P 0.12623f
C1836 HS_P_6 HS_N_1 0.06023f
C1837 FS_P_BLEED_5 HS_N_4 0.06178f
C1838 TERM_VCM FS_HIGH_N 0.07041f
C1839 FS_HIGH_N PULLDOWN_P 0.03743f
C1840 FS_P_WELL HS_P_12 0.00134f
C1841 TERM_N_R FS_P_OUT 0.38548f
C1842 HS_N_13 HS_P_3 0.02464f
C1843 FS_P_BLEED_0 HS_PBIAS 0.08856f
C1844 PULLUP_N_OUT TERM_OR_N_NS 0.05397f
C1845 PULLUP_P_CONTROL_S PULLDOWN_N_R 0.08753f
C1846 PULLUP_N_BLEED_3 PULLUP_P 0.05126f
C1847 FS_N_BLEED_0 PULLUP_N_WELL 0
C1848 FS_N_OUT DIV_LOW_P 0.05525f
C1849 a_41005_134065# ESD_RAIL 0.57348f
C1850 FS_P_BLEED_2 PULLUP_P_GATE 0
C1851 TERM_OR_P_B PULLDOWN_N_R 0.16954f
C1852 FS_N_GATE FS_N_BLEED_6 2.79368f
C1853 HS_N_0 HS_N 0.13467p
C1854 PAD_N HS_N_8 1.07245f
C1855 HS_N_13 HS_N_12 0.1359p
C1856 HS_N_4 HS_P_10 0.07706f
C1857 FS_P_BLEED_5 HS_N_11 0.06178f
C1858 HS_N FS_N_WELL 4.96692f
C1859 PULLUP_N_OUT HS_N_0 0.05062f
C1860 FS_P_BLEED_6 HS_N_5 0.06178f
C1861 PULLUP_N_BLEED_0 PULLDOWN_P 0.06517f
C1862 FS_P_GATE HS_P_12 0.00294f
C1863 VCM_LOW_OK PULLDOWN_P_R 0.06553f
C1864 FS_P_WELL HS_N 41.6575f
C1865 PULLUP_N_OUT FS_N_WELL 2.10234f
C1866 TERM_OR_N_NS TERM_ENABLE 0.10081f
C1867 HS_P_4 HS_PBIAS 8.54683f
C1868 FS_P_BLEED_0 TERM_P_R 0.11348f
C1869 VCM_LOW_OK DIV_ENABLE 0
C1870 HS_N_3 HS_PBIAS 1.07017f
C1871 HS_N_11 HS_P_10 0.1403f
C1872 PULLUP_N_OUT FS_P_WELL 2.65652f
C1873 DIV_LOW_N HS_PBIAS 0.09646f
C1874 PULLUP_P_BLEED_5 HS_N_1 0.02451f
C1875 TERM_OR_P_B HS_P_9 0.1442f
C1876 PULLUP_P_OUT PULLUP_P 0.00257f
C1877 TERM_N_R TERM_GATE_P_BLEED_1 0.23767f
C1878 FS_LOW_P HS_P_0 0.0932f
C1879 TERM_GATE_N_BLEED_1 FS_LOW_P 0.05872f
C1880 DIV_N FS_HIGH_P 8.67054f
C1881 HS_P_13 HS_P_7 0.14204f
C1882 TERM_GATE_N_BLEED_0 HS_N_1 0.03489f
C1883 PULLUP_P_BLEED_2 PULLUP_P 0.14463f
C1884 HS_N_2 VCM_LOW_OK 0.05893f
C1885 TERM_N_R VDD 6.88046f
C1886 VCM_LOW_OK HS_P_11 0.06673f
C1887 HS_P_13 HS_P_12 47.0352f
C1888 TERM_VCM HS_PBIAS 0.70648f
C1889 FS_P_GATE HS_N 2.29474f
C1890 HS_N_0 TERM_ENABLE 0.10582f
C1891 PULLDOWN_P HS_PBIAS 0.44043f
C1892 HS_N_10 HS_PBIAS 1.13923f
C1893 FS_N_OUT FS_LOW_P 0.5386f
C1894 TERM_ENABLE FS_N_WELL 2.50751f
C1895 PULLUP_N_OUT FS_P_GATE 1.30807f
C1896 HS_N_7 PULLUP_P_WELL 0.12519f
C1897 DIV_N PULLDOWN_N_R 0.0471f
C1898 FS_N_CONTROL_S HS_P 0.09439f
C1899 TERM_P_R HS_P_4 0.1254f
C1900 HS_P PULLDOWN_P_R 0.03048f
C1901 HS_N_5 HS_P_6 0.05828f
C1902 PULLUP_P_BLEED_3 PULLUP_P_BLEED_0 0.0078f
C1903 HS_P DIV_ENABLE 0.03818f
C1904 PULLUP_N_BLEED_2 PULLDOWN_P 0.08014f
C1905 TERM_OR_N_NS HS_N_0 0.03425f
C1906 HS_N_3 TERM_P_R 0.05893f
C1907 FS_P_WELL TERM_ENABLE 2.50111f
C1908 DIV_LOW_N TERM_P_R 0.0414f
C1909 TERM_GATE_P HS_P_10 0.17903f
C1910 PULLUP_P_CONTROL_S HS_N_4 0.04808f
C1911 HS_P DIFF_ENABLE 0.27285f
C1912 TERM_N_R PULLUP_N_GATE 0.17473f
C1913 BYPASS_ENABLE VDD 0.03959f
C1914 HS_P_13 HS_N 0.35374f
C1915 TERM_N_R TERM_OR_N_S 0.12114f
C1916 PULLUP_P PULLUP_N 0.03743f
C1917 DIV_ENABLE DIV_LOW_P 2.67093f
C1918 FS_P_BLEED_4 HS_N_3 0.06178f
C1919 HS_N_4 TERM_OR_P_B 0.07211f
C1920 FS_P_BLEED_0 FS_P_BLEED_1 8.76361f
C1921 TERM_P_R TERM_VCM 0.19926p
C1922 TERM_P_R PULLDOWN_P 0.04141f
C1923 DIV_N PAD_P 0.45367f
C1924 HS_N_2 HS_P 0.85293f
C1925 HS_N_10 TERM_P_R 0.06034f
C1926 TERM_N_R FS_LOW_N 0.11177f
C1927 PULLUP_N_WELL PULLUP_N_BLEED_3 0
C1928 TERM_OR_N_B TERM_GATE_N_BLEED_0 0.00163f
C1929 HS_P_13 HS_P_8 0.05624f
C1930 HS_N_8 HS_PBIAS 3.45151f
C1931 HS_P HS_P_11 5.65023f
C1932 HS_N_12 PULLUP_P_WELL 0.12571f
C1933 HS_N_6 HS_N_5 0.12181p
C1934 FS_P_GATE TERM_ENABLE 1.00704f
C1935 PULLUP_N_OUT HS_P_13 0.02868f
C1936 FS_N_OUT FS_P_BLEED_2 0.15927f
C1937 a_41005_132385# m2_42279_124800# 0
C1938 FS_N_GATE HS_N_12 0.01973f
C1939 TERM_GATE_P_BLEED_0 HS_P_6 0.02404f
C1940 PULLUP_P_CONTROL_S HS_N_11 0.04911f
C1941 HS_N_2 DIV_LOW_P 0
C1942 HS_N_11 TERM_OR_P_B 0.07338f
C1943 FS_P_BLEED_4 HS_N_10 0.06178f
C1944 FS_N_BLEED_1 FS_HIGH_N 0.01132f
C1945 PULLUP_N_BLEED_4 TERM_VCM 0.02041f
C1946 PULLUP_N_BLEED_6 PULLUP_N_BLEED_5 4.58267f
C1947 FS_P_WELL HS_N_0 2.61482f
C1948 PULLUP_N_BLEED_4 PULLDOWN_P 0
C1949 HS_N_9 HS_P_7 0.0401f
C1950 HS_N_9 HS_P_12 0.06578f
C1951 FS_P_OUT VCM_LOW_OK 0.37711f
C1952 PULLUP_P_BLEED_5 HS_N_5 0.03089f
C1953 FS_N_BLEED_4 TERM_VCM 0.04263f
C1954 FS_N_BLEED_4 PULLDOWN_P 0.04811f
C1955 HS_N_6 TERM_GATE_P_BLEED_0 0
C1956 TERM_P_R HS_N_8 0.05914f
C1957 HS_N_6 PULLUP_P_BLEED_4 0.0525f
C1958 HS_P_13 TERM_ENABLE 0.02404f
C1959 HS_N_3 FS_P_BLEED_1 0.03472f
C1960 TERM_GATE_N_BLEED_0 HS_N_5 0.03489f
C1961 PULLUP_P_OUT HS_P_2 0.06773f
C1962 TERM_GATE_N_BLEED_2 HS_PBIAS 0.17672f
C1963 HS_N_0 FS_P_GATE 1.02982f
C1964 HS_N_7 FS_HIGH_P 0.02404f
C1965 FS_LOW_P PULLDOWN_P_R 0.06539f
C1966 FS_N_CONTROL_S FS_LOW_P 0.04634f
C1967 FS_P_BLEED_4 HS_N_8 0.06266f
C1968 DIV_N HS_N_4 0.03462f
C1969 FS_LOW_P DIV_ENABLE 0.10881f
C1970 HS_N_13 PAD_N 1.56314f
C1971 HS_N_9 HS_N 5.97147f
C1972 HS_N_7 PULLDOWN_N_R 0.06832f
C1973 TERM_VCM FS_P_BLEED_1 0.03472f
C1974 TERM_OR_P_B TERM_GATE_P 12.9405f
C1975 PULLUP_N_GATE PULLUP_N_BLEED_1 0.05777f
C1976 HS_N_9 HS_P_8 0.10431f
C1977 HS_N_10 FS_P_BLEED_1 0.03472f
C1978 FS_P_WELL FS_P_GATE 0.26394p
C1979 FS_P_OUT HS_P 0.68531f
C1980 HS_N_9 PULLUP_N_OUT 0.01492f
C1981 DIV_N PULLUP_P_BLEED_3 0.10151f
C1982 FS_LOW_P DIFF_ENABLE 0.27413f
C1983 PULLUP_P_BLEED_5 PULLUP_P_BLEED_4 4.64605f
C1984 HS_N_2 FS_LOW_P 0.08505f
C1985 HS_N_12 FS_HIGH_P 0.02428f
C1986 DIV_N HS_N_11 0.03462f
C1987 HS_P_3 PULLDOWN_N_R 0.07217f
C1988 TERM_OR_P_S TERM_VCM 0.05962f
C1989 HS_N_0 HS_P_13 0.02661f
C1990 FS_LOW_P HS_P_11 0.05239f
C1991 PULLUP_P_BLEED_6 HS_PBIAS 0.01633f
C1992 FS_P_BLEED_6 TERM_N_R 0.05729f
C1993 FS_N_BLEED_1 HS_PBIAS 0.08856f
C1994 FS_P_OUT DIV_LOW_P 0.13605f
C1995 VCM_LOW_OK VDD 57.507f
C1996 PAD_P RX_P 8.57241f
C1997 PULLUP_P_GATE HS_N_3 0.08296f
C1998 HS_N_7 PAD_P 0.03829f
C1999 PULLUP_N_WELL PULLUP_N 0.61243f
C2000 HS_N_12 PULLDOWN_N_R 0.06832f
C2001 FS_P_BLEED_1 HS_N_8 0.03472f
C2002 FS_P_WELL HS_P_13 0.19945f
C2003 HS_P_12 HS_N_1 0.06335f
C2004 VCM_LOW_OK HS_P_5 0.03489f
C2005 HS_N_9 TERM_ENABLE 0.04808f
C2006 FS_P_BLEED_2 DIV_ENABLE 0
C2007 PAD_P HS_P_3 1.68578f
C2008 PULLUP_P_GATE HS_N_10 0.08357f
C2009 TERM_GATE_P_BLEED_2 TERM_GATE_P 0.40344f
C2010 PULLUP_P_GATE TERM_VCM 0.12603f
C2011 PULLUP_P_GATE PULLDOWN_P 0.02056f
C2012 VCM_LOW_OK TERM_OR_N_S 2.91765f
C2013 HS_P_3 HS_P_9 0.04194f
C2014 HS_N_12 PAD_P 2.18792f
C2015 DIV_N TERM_GATE_P 0.00178f
C2016 HS_N_9 TERM_OR_N_NS 0.03425f
C2017 HS_P VDD 1.62825f
C2018 VCM_LOW_OK FS_LOW_N 0.22524f
C2019 HS_N HS_N_1 4.22798f
C2020 FS_P_GATE HS_P_13 0.19446f
C2021 VCM_LOW_OK HS_P_1 0.03489f
C2022 HS_N_13 HS_PBIAS 7.29451f
C2023 HS_P HS_P_5 5.05127f
C2024 HS_N_7 HS_N_4 0.07687f
C2025 FS_P_OUT FS_LOW_P 0.53029f
C2026 HS_N_9 HS_N_0 0.04157f
C2027 PULLUP_P_GATE HS_N_8 0.08595f
C2028 FS_N_OUT FS_P_BLEED_0 0.28479f
C2029 TERM_N_R FS_N_BLEED_2 0.05729f
C2030 HS_N_9 FS_N_WELL 0.00889f
C2031 DIV_N RX_N 1.36638f
C2032 HS_N_7 PULLUP_P_BLEED_3 0.03489f
C2033 FS_N_BLEED_4 FS_N_BLEED_1 0.0078f
C2034 PULLUP_N_GATE HS_P 0.11746f
C2035 TERM_OR_N_S HS_P 0.05632f
C2036 DIV_N TERM_GATE_N 0.02552f
C2037 DIV_LOW_P HS_P_5 0.00305f
C2038 HS_N_6 TERM_N_R 0.1093f
C2039 HS_N_9 FS_P_WELL 2.02035f
C2040 FS_N_GATE FS_HIGH_N 8.87893f
C2041 HS_N_4 HS_P_3 0.00972f
C2042 TERM_N_R PULLUP_P_BLEED_1 0.05729f
C2043 HS_N_7 HS_N_11 0.02985f
C2044 HS_P FS_LOW_N 0.08532f
C2045 PULLUP_P PULLUP_N_BLEED_5 0.10721f
C2046 HS_N_13 TERM_P_R 0.0965f
C2047 PULLUP_P PULLUP_P_BLEED_0 0.82084f
C2048 HS_N_12 HS_N_4 0
C2049 TERM_ENABLE HS_N_1 0.04872f
C2050 HS_P_4 HS_P_0 0.00219f
C2051 HS_P HS_P_1 4.17389f
C2052 FS_P_BLEED_3 HS_P 0.0834f
C2053 HS_P_12 HS_N_5 0.06578f
C2054 TERM_GATE_N_BLEED_1 HS_N_3 0.0525f
C2055 HS_N_11 HS_P_3 0.02508f
C2056 TERM_OR_N_B PULLUP_N_OUT 0.09609f
C2057 FS_N_OUT HS_N_3 0.06167f
C2058 TERM_OR_P_NS PULLDOWN_N_R 0.04591f
C2059 HS_N_12 PULLUP_P_BLEED_3 0.03489f
C2060 FS_P_BLEED_2 FS_P_OUT 0
C2061 HS_N_13 FS_P_BLEED_4 0.06178f
C2062 HS_N_9 FS_P_GATE 1.05196f
C2063 TERM_OR_P_B DIV_P 0.0223f
C2064 FS_N_OUT DIV_LOW_N 0.11535f
C2065 TERM_OR_N_NS HS_N_1 0.03425f
C2066 PULLUP_P_CONTROL_S PULLUP_P 6.1629f
C2067 HS_N_12 HS_N_11 0.1373p
C2068 TERM_N_R TERM_GATE_N_BLEED_0 0.17977f
C2069 TERM_VCM HS_P_0 0.19537f
C2070 FS_LOW_P VDD 3.59076f
C2071 TERM_GATE_N_BLEED_1 TERM_VCM 0.00966f
C2072 TERM_GATE_N_BLEED_1 PULLDOWN_P 0.07928f
C2073 TERM_GATE_N_BLEED_1 HS_N_10 0.0527f
C2074 a_41005_132945# m2_42279_124800# 0
C2075 HS_N_10 HS_P_0 0.06989f
C2076 FS_N_OUT TERM_VCM 0.42885f
C2077 FS_P_BLEED_6 VCM_LOW_OK 0.01451f
C2078 HS_N_7 TERM_GATE_P 0.12198f
C2079 FS_N_OUT PULLDOWN_P 0.57337f
C2080 HS_N HS_N_5 4.65354f
C2081 TERM_GATE_P_BLEED_0 HS_P_7 0.02404f
C2082 HS_P_12 TERM_GATE_P_BLEED_0 0.03636f
C2083 HS_N_0 HS_N_1 0.12498p
C2084 FS_LOW_P HS_P_5 0.17341f
C2085 HS_P_2 HS_P_10 0
C2086 TERM_OR_N_B TERM_ENABLE 1.2192f
C2087 HS_N_9 HS_P_13 0.05493f
C2088 PULLUP_P_WELL HS_PBIAS 0.52241f
C2089 PULLUP_N_OUT HS_N_5 0.04773f
C2090 TERM_GATE_N_BLEED_0 BYPASS_ENABLE 0.00766f
C2091 TERM_GATE_P HS_P_3 0.15659f
C2092 TERM_OR_P_NS HS_P_9 0.03937f
C2093 PULLUP_P_GATE PULLUP_P_BLEED_6 1.78667f
C2094 FS_P_WELL HS_N_1 2.10428f
C2095 FS_P_BLEED_0 PULLDOWN_P_R 0.10124f
C2096 FS_HIGH_N FS_HIGH_P 29.9593f
C2097 FS_N_GATE HS_PBIAS 3.08633f
C2098 PAD_N PULLDOWN_N_R 4.48191f
C2099 HS_N_13 FS_P_BLEED_1 0.03472f
C2100 PULLUP_N_BLEED_3 PULLUP_N 0.121f
C2101 PULLUP_N_GATE FS_LOW_P 0.10761f
C2102 RX_N RX_P 20.1628f
C2103 TERM_GATE_N_BLEED_1 HS_N_8 0.0525f
C2104 HS_N_8 HS_P_0 0.03523f
C2105 TERM_OR_N_B TERM_OR_N_NS 1.66751f
C2106 HS_N_12 TERM_GATE_P 0.10814f
C2107 FS_LOW_P FS_LOW_N 93.3684f
C2108 FS_HIGH_N PULLDOWN_N_R 0.03743f
C2109 HS_N_7 TERM_GATE_N 0.05007f
C2110 FS_N_OUT HS_N_8 0.06167f
C2111 FS_P_BLEED_6 HS_P 0.06178f
C2112 PULLUP_P_BLEED_4 HS_N 0.10264f
C2113 DIV_N DIV_P 48.6079f
C2114 TERM_GATE_P_BLEED_0 HS_P_8 0.0271f
C2115 FS_LOW_P HS_P_1 0.11262f
C2116 VCM_LOW_OK HS_P_6 0.03489f
C2117 PULLUP_N_OUT TERM_GATE_P_BLEED_0 0.10679f
C2118 PAD_N PAD_P 58.971f
C2119 HS_N_5 TERM_ENABLE 0.08996f
C2120 HS_N_2 FS_P_BLEED_0 0.06178f
C2121 FS_P_GATE HS_N_1 1.0435f
C2122 PULLUP_N_OUT PULLUP_P_BLEED_4 0.09196f
C2123 DIV_N PULLUP_P 0.04512f
C2124 PULLUP_N_BLEED_0 FS_HIGH_P 0.01347f
C2125 PULLUP_P_WELL TERM_P_R 0.29295f
C2126 PULLDOWN_P_R HS_P_4 0.07466f
C2127 FS_N_GATE TERM_P_R 0.72109f
C2128 PAD_N HS_P_9 6.47937f
C2129 HS_N_4 TERM_OR_P_NS 0.00196f
C2130 HS_N_3 PULLDOWN_P_R 0.02404f
C2131 TERM_OR_N_NS HS_N_5 0.03425f
C2132 HS_N_3 DIV_ENABLE 0.03089f
C2133 PULLUP_N_BLEED_0 PULLDOWN_N_R 0.07928f
C2134 HS_N_7 FS_P_CONTROL_S 0.03226f
C2135 HS_N_12 TERM_GATE_N 0.04844f
C2136 PULLUP_P_WELL FS_P_BLEED_4 0
C2137 HS_N_13 PULLUP_P_GATE 0.08296f
C2138 TERM_GATE_N_BLEED_2 TERM_GATE_N_BLEED_1 5.57305f
C2139 HS_N_6 VCM_LOW_OK 0.05893f
C2140 DIV_LOW_N DIV_ENABLE 9.85993f
C2141 TERM_N_R FS_N_BLEED_3 0.11444f
C2142 PULLUP_P_BLEED_1 VCM_LOW_OK 0.01462f
C2143 TERM_ENABLE TERM_GATE_P_BLEED_0 0.09803f
C2144 FS_N_CONTROL_S TERM_VCM 0.07594f
C2145 FS_N_CONTROL_S PULLDOWN_P 0.09439f
C2146 TERM_VCM PULLDOWN_P_R 0.22328f
C2147 HS_P HS_P_6 3.46603f
C2148 TERM_OR_P_B HS_P_2 0.10307f
C2149 PULLDOWN_P PULLDOWN_P_R 2.2366f
C2150 FS_P_BLEED_3 FS_P_BLEED_2 0.53961f
C2151 HS_N_10 PULLDOWN_P_R 0.02436f
C2152 HS_P_13 HS_N_1 0.12155f
C2153 HS_P_11 HS_P_4 0
C2154 FS_HIGH_P HS_PBIAS 0.07608f
C2155 HS_N_0 HS_N_5 0.04157f
C2156 TERM_VCM DIV_ENABLE 0.20793f
C2157 DIV_ENABLE PULLDOWN_P 0.04428f
C2158 HS_N_2 HS_N_3 0.12365p
C2159 HS_N_10 DIV_ENABLE 0.03182f
C2160 FS_N_BLEED_4 FS_N_GATE 0.27893f
C2161 HS_N_2 DIV_LOW_N 0.06178f
C2162 HS_N_12 FS_P_CONTROL_S 0.03226f
C2163 PULLUP_P_BLEED_5 VCM_LOW_OK 0
C2164 HS_N_4 PAD_N 1.29614f
C2165 PULLDOWN_N_R HS_PBIAS 0.82033f
C2166 TERM_OR_N_NS PULLUP_P_BLEED_4 0
C2167 TERM_VCM DIFF_ENABLE 0.14773f
C2168 DIFF_ENABLE PULLDOWN_P 0.21707f
C2169 FS_P_WELL HS_N_5 1.97115f
C2170 HS_P FS_N_BLEED_2 0.08856f
C2171 HS_N_2 TERM_VCM 0.12019f
C2172 TERM_VCM HS_P_11 0.13824f
C2173 PULLUP_N_BLEED_2 PULLDOWN_N_R 0.05146f
C2174 HS_N_2 HS_N_10 0.03509f
C2175 HS_N_6 HS_P 1.04391f
C2176 PULLUP_P_WELL FS_P_BLEED_1 0.00137f
C2177 HS_N_10 HS_P_11 0.00351f
C2178 PULLDOWN_P_R HS_N_8 0.02404f
C2179 HS_N_11 PAD_N 1.22201f
C2180 DIV_ENABLE HS_N_8 0.03089f
C2181 HS_N_0 PULLUP_P_BLEED_4 0.05293f
C2182 FS_P_GATE HS_N_5 1.04072f
C2183 RX_P DIV_P 1.39534f
C2184 TERM_P_R PULLDOWN_N_R 0.14117f
C2185 HS_N_7 PULLUP_P 0.07466f
C2186 HS_P_9 HS_PBIAS 3.39603f
C2187 PULLUP_P_BLEED_5 HS_P 0.10446f
C2188 HS_N_2 HS_N_8 0.00333f
C2189 HS_P_11 HS_N_8 0.02857f
C2190 TERM_GATE_N_BLEED_0 HS_P 0.03489f
C2191 FS_P_BLEED_4 PULLDOWN_N_R 0.05822f
C2192 FS_P_OUT HS_N_3 0.48792f
C2193 TERM_N_R HS_N 0.14159f
C2194 FS_P_BLEED_6 FS_P_BLEED_2 0.06814f
C2195 PULLUP_P_WELL PULLUP_P_GATE 35.6995f
C2196 FS_N_BLEED_4 FS_HIGH_P 0.09418f
C2197 PULLUP_N_BLEED_4 PULLDOWN_N_R 0
C2198 HS_N_13 TERM_GATE_N_BLEED_1 0.0525f
C2199 FS_LOW_P HS_P_6 0.04566f
C2200 a_41005_131545# a_43813_117064# 2.44008f
C2201 HS_P_13 HS_N_5 0.05493f
C2202 TERM_N_R PULLUP_N_OUT 0.30705f
C2203 TERM_P_R PAD_P 0.63614f
C2204 HS_N_12 PULLUP_P 0.0678f
C2205 FS_N_BLEED_6 PULLUP_N_WELL 0
C2206 FS_N_BLEED_4 PULLDOWN_N_R 0.04811f
C2207 FS_P_BLEED_0 VDD 0.66399f
C2208 FS_P_OUT TERM_VCM 0.38638f
C2209 PULLUP_N_BLEED_6 FS_HIGH_N 0.15562f
C2210 FS_P_OUT HS_N_10 0.44249f
C2211 TERM_P_R HS_P_9 0.11568f
C2212 FS_LOW_P FS_N_BLEED_2 0.14463f
C2213 PULLUP_P_OUT FS_P_BLEED_5 0.05047f
C2214 PULLDOWN_N HS_PBIAS 0.03743f
C2215 TERM_P_R PULLUP_N_CONTROL_S 0.0414f
C2216 HS_N_4 HS_PBIAS 2.61651f
C2217 FS_P_BLEED_1 FS_HIGH_P 0.16649f
C2218 HS_N BYPASS_ENABLE 0.01049f
C2219 HS_N_6 FS_LOW_P 0.08542f
C2220 HS_N_2 TERM_GATE_N_BLEED_2 0.02404f
C2221 a_41005_133505# m2_42279_124800# 0
C2222 TERM_OR_N_B HS_N_9 0
C2223 PULLUP_P_BLEED_3 HS_PBIAS 0.04828f
C2224 PAD_N RX_N 9.47377f
C2225 FS_P_BLEED_1 PULLDOWN_N_R 0.05445f
C2226 PULLUP_P_BLEED_6 PULLDOWN_P_R 0.19409f
C2227 HS_P_13 TERM_GATE_P_BLEED_0 0.0256f
C2228 PULLUP_N_BLEED_3 PULLUP_N_BLEED_5 0.10602f
C2229 TERM_N_R TERM_ENABLE 0.4835f
C2230 PULLUP_P_OUT HS_P_10 0.05276f
C2231 PULLUP_N_BLEED_0 PULLUP_N_BLEED_6 0.00257f
C2232 HS_N_11 HS_PBIAS 2.65494f
C2233 VDD HS_P_4 4.77123f
C2234 FS_P_OUT HS_N_8 0.43367f
C2235 HS_N_3 VDD 5.65374f
C2236 DIV_LOW_N VDD 0.25658f
C2237 TERM_P_R PULLDOWN_N 0.05332f
C2238 HS_N_4 TERM_P_R 0.05893f
C2239 TERM_N_R TERM_OR_N_NS 0.04867f
C2240 HS_P_4 HS_P_5 32.9896f
C2241 TERM_GATE_N_BLEED_0 FS_LOW_P 0.06271f
C2242 HS_N PULLUP_N_BLEED_1 0.06387f
C2243 HS_N_9 HS_N_5 0.04079f
C2244 PULLUP_P_BLEED_3 TERM_P_R 0.04766f
C2245 TERM_VCM VDD 40.0347f
C2246 PULLUP_P_GATE FS_HIGH_P 0.03189f
C2247 HS_N_3 HS_P_5 0.03489f
C2248 VDD PULLDOWN_P 1.70977f
C2249 HS_N_10 VDD 6.378f
C2250 FS_P_BLEED_4 HS_N_4 0.06178f
C2251 PULLUP_N_OUT PULLUP_N_BLEED_1 0
C2252 PULLUP_N_BLEED_6 HS_PBIAS 0.04828f
C2253 HS_N_3 TERM_OR_N_S 0.02557f
C2254 FS_N_BLEED_3 HS_P 0.08856f
C2255 PULLUP_P_GATE PULLDOWN_N_R 0.23555f
C2256 VCM_LOW_OK HS_P_7 0.03489f
C2257 TERM_N_R HS_N_0 0.13438f
C2258 HS_N_11 TERM_P_R 0.05996f
C2259 VCM_LOW_OK HS_P_12 0.03489f
C2260 TERM_N_R FS_N_WELL 1.45715f
C2261 HS_N_3 FS_LOW_N 0.08441f
C2262 HS_N_10 HS_P_5 0.03489f
C2263 TERM_VCM HS_P_5 0.09615f
C2264 TERM_GATE_P HS_PBIAS 0.02241f
C2265 HS_P_2 HS_P_3 34.3283f
C2266 HS_N_13 PULLDOWN_P_R 0.02404f
C2267 PULLUP_N_BLEED_2 PULLUP_N_BLEED_6 0.00257f
C2268 PULLUP_P_BLEED_2 PULLUP_P_BLEED_0 0.10891f
C2269 TERM_N_R FS_P_WELL 1.63349f
C2270 DIV_LOW_N FS_LOW_N 0.06178f
C2271 FS_N_OUT PULLUP_P_WELL 0.13784f
C2272 HS_P_1 HS_P_4 0.03207f
C2273 FS_P_BLEED_4 HS_N_11 0.06178f
C2274 HS_N_13 DIV_ENABLE 0.03089f
C2275 TERM_VCM TERM_OR_N_S 0
C2276 FS_P_BLEED_3 HS_N_3 0.03144f
C2277 HS_N_9 TERM_GATE_P_BLEED_0 0.00105f
C2278 PULLUP_N_GATE TERM_VCM 0.19338f
C2279 PULLUP_N_GATE PULLDOWN_P 0.18497f
C2280 TERM_OR_N_S PULLDOWN_P 0.10193f
C2281 FS_N_OUT FS_N_GATE 0.14435p
C2282 HS_N_10 TERM_OR_N_S 0.02545f
C2283 HS_N_9 PULLUP_P_BLEED_4 0.0525f
C2284 VDD HS_N_8 4.98108f
C2285 TERM_VCM FS_LOW_N 0.11348f
C2286 HS_N_10 FS_LOW_N 0.08441f
C2287 PULLUP_P_OUT TERM_OR_P_B 0.19951f
C2288 TERM_P_R PULLUP_N_BLEED_6 0.04797f
C2289 FS_LOW_N PULLDOWN_P 0.32402f
C2290 VCM_LOW_OK HS_N 0.07865f
C2291 HS_N_4 FS_P_BLEED_1 0.03472f
C2292 HS_N_2 HS_N_13 0.12568p
C2293 BYPASS_ENABLE FS_N_WELL 0.05619f
C2294 VCM_LOW_OK HS_P_8 0.03489f
C2295 TERM_P_R TERM_GATE_P 26.175f
C2296 HS_P HS_P_7 0.53303f
C2297 TERM_VCM HS_P_1 0.15005f
C2298 FS_P_BLEED_3 HS_N_10 0.02915f
C2299 TERM_N_R FS_P_GATE 0.81322f
C2300 HS_P_12 HS_P 3.63983f
C2301 TERM_GATE_N HS_PBIAS 0.13841f
C2302 HS_N_8 HS_P_5 0.05893f
C2303 PULLUP_N PULLUP_N_BLEED_5 0.06639f
C2304 PULLUP_N_OUT VCM_LOW_OK 0.20396f
C2305 FS_P_WELL BYPASS_ENABLE 0.05062f
C2306 PULLUP_N_BLEED_4 PULLUP_N_BLEED_6 0.00855f
C2307 PAD_N DIV_P 0.47479f
C2308 TERM_OR_N_S HS_N_8 0.03108f
C2309 HS_N_5 HS_N_1 0
C2310 HS_N_11 FS_P_BLEED_1 0.03472f
C2311 FS_LOW_N HS_N_8 0.1267f
C2312 FS_N_BLEED_3 FS_LOW_P 0.10387f
C2313 HS_N HS_P 2.27647f
C2314 HS_P_1 HS_N_8 0.02866f
C2315 FS_P_BLEED_3 HS_N_8 0.04176f
C2316 TERM_GATE_N_BLEED_1 FS_HIGH_P 0.01347f
C2317 FS_P_CONTROL_S HS_PBIAS 0.04861f
C2318 TERM_GATE_N TERM_P_R 0.1818f
C2319 HS_P HS_P_8 3.0077f
C2320 VCM_LOW_OK TERM_ENABLE 0.27311f
C2321 PULLUP_P FS_HIGH_N 0.04377f
C2322 PULLUP_P_OUT TERM_GATE_P_BLEED_2 0.04242f
C2323 PULLUP_P_GATE HS_N_4 0.08296f
C2324 FS_N_OUT FS_HIGH_P 0.17276f
C2325 FS_P_BLEED_6 HS_N_3 0.06178f
C2326 PULLUP_N_OUT HS_P 0.09327f
C2327 PULLUP_P_OUT DIV_N 0
C2328 TERM_GATE_N_BLEED_1 PULLDOWN_N_R 0.07928f
C2329 HS_N DIV_LOW_P 0.06611f
C2330 PULLUP_P_BLEED_4 HS_N_1 0.05286f
C2331 PULLDOWN_N_R HS_P_0 0.03037f
C2332 PULLUP_P_GATE PULLUP_P_BLEED_3 0.23044f
C2333 TERM_OR_N_NS VCM_LOW_OK 7.88232f
C2334 PULLUP_P_WELL PULLDOWN_P_R 0.59282f
C2335 PULLUP_P_WELL DIV_ENABLE 0.01343f
C2336 FS_N_OUT PULLDOWN_N_R 0.56245f
C2337 FS_N_GATE FS_N_CONTROL_S 0.98908f
C2338 PULLUP_P_GATE HS_N_11 0.08345f
C2339 HS_N_13 FS_P_OUT 0.52823f
C2340 FS_N_GATE DIV_ENABLE 0.004f
C2341 FS_LOW_P FS_N_BLEED_5 0.12388f
C2342 FS_N_BLEED_1 VDD 0.00299f
C2343 FS_P_BLEED_6 TERM_VCM 0.01859f
C2344 FS_P_BLEED_6 HS_N_10 0.06178f
C2345 TERM_OR_P_NS HS_P_2 0.02846f
C2346 FS_LOW_P HS_P_7 0.04566f
C2347 HS_N_0 VCM_LOW_OK 0.05893f
C2348 TERM_ENABLE HS_P 0.05441f
C2349 HS_P_12 FS_LOW_P 0.17418f
C2350 PAD_P HS_P_0 1.64024f
C2351 HS_N_6 FS_P_BLEED_0 0.06178f
C2352 HS_N_2 PULLUP_P_WELL 0.11473f
C2353 FS_N_OUT PAD_P 0.17964f
C2354 HS_P_6 HS_P_4 0.06956f
C2355 HS_N_3 HS_P_6 0.05828f
C2356 HS_N_9 TERM_N_R 0.0592f
C2357 TERM_OR_N_NS HS_P 0.03425f
C2358 FS_P_WELL VCM_LOW_OK 1.23126f
C2359 PULLUP_P HS_PBIAS 0.35017f
C2360 PULLUP_P_BLEED_6 FS_LOW_N 0.02395f
C2361 FS_N_BLEED_1 FS_LOW_N 0.00106f
C2362 FS_P_BLEED_6 HS_N_8 0.06178f
C2363 HS_N FS_LOW_P 0.10015f
C2364 PAD_N HS_P_2 2.43754f
C2365 HS_N_10 HS_P_6 0.0597f
C2366 FS_LOW_P HS_P_8 0.04566f
C2367 HS_N_6 HS_P_4 0.03738f
C2368 TERM_VCM HS_P_6 0.09619f
C2369 PULLUP_N_OUT FS_LOW_P 0.07132f
C2370 HS_N_13 VDD 7.11098f
C2371 HS_N_0 HS_P 0.16427f
C2372 FS_P_GATE VCM_LOW_OK 1.23568f
C2373 HS_N_6 HS_N_3 0.04183f
C2374 HS_P FS_N_WELL 2.92153f
C2375 TERM_P_R DIV_P 0.02242f
C2376 PULLDOWN_P_R FS_HIGH_P 0.04377f
C2377 HS_N_5 TERM_GATE_P_BLEED_0 0
C2378 FS_P_CONTROL_S FS_P_BLEED_1 0
C2379 HS_N_6 DIV_LOW_N 0.06178f
C2380 TERM_GATE_N_BLEED_1 HS_N_4 0.0525f
C2381 PULLUP_N_WELL FS_HIGH_N 0.30788f
C2382 TERM_VCM FS_N_BLEED_2 0.02041f
C2383 PULLUP_P_BLEED_4 HS_N_5 0.0525f
C2384 DIV_ENABLE FS_HIGH_P 4.86998f
C2385 HS_N_4 HS_P_0 0.03432f
C2386 HS_N_13 HS_P_5 0.03489f
C2387 PULLDOWN_P FS_N_BLEED_2 0.08856f
C2388 FS_P_WELL HS_P 2.08315f
C2389 HS_N_0 DIV_LOW_P 0.00585f
C2390 PULLUP_P_OUT HS_N_7 0.03489f
C2391 TERM_P_R PULLUP_P 0.1121f
C2392 FS_N_CONTROL_S PULLDOWN_N_R 0.09439f
C2393 PULLDOWN_P_R PULLDOWN_N_R 33.296f
C2394 HS_N_6 TERM_VCM 0.17751f
C2395 HS_N_6 PULLDOWN_P 0.04428f
C2396 HS_N_6 HS_N_10 0
C2397 DIFF_ENABLE FS_HIGH_P 0.2074f
C2398 DIV_ENABLE PULLDOWN_N_R 0.04455f
C2399 PULLUP_P_BLEED_1 TERM_VCM 0.01882f
C2400 HS_N_13 TERM_OR_N_S 0.02464f
C2401 PULLUP_P_BLEED_5 HS_N_3 0.02807f
C2402 FS_P_BLEED_2 HS_N 0.01113f
C2403 FS_LOW_P TERM_ENABLE 0.13548f
C2404 TERM_GATE_N_BLEED_1 HS_N_11 0.05266f
C2405 FS_N_OUT PULLUP_P_BLEED_3 0.06167f
C2406 HS_P_6 HS_N_8 0.04808f
C2407 HS_N_2 FS_HIGH_P 0.02404f
C2408 HS_N_11 HS_P_0 0.04389f
C2409 TERM_GATE_N_BLEED_0 HS_N_3 0.03489f
C2410 PULLUP_P_OUT HS_P_3 0.05276f
C2411 VCM_LOW_OK HS_P_13 0.03489f
C2412 HS_N_13 FS_LOW_N 0.08441f
C2413 PULLUP_N_BLEED_4 PULLUP_P 0.10721f
C2414 DIFF_ENABLE PULLDOWN_N_R 0.23599f
C2415 PULLUP_N_BLEED_0 PULLUP_N_WELL 5.00789f
C2416 TERM_OR_P_B HS_P_10 0.09644f
C2417 FS_P_GATE HS_P 1.05827f
C2418 PULLUP_P_OUT HS_N_12 0.03489f
C2419 TERM_N_R HS_N_1 0.06392f
C2420 HS_N_2 PULLDOWN_N_R 0.02404f
C2421 FS_P_BLEED_3 HS_N_13 0.02846f
C2422 HS_P_11 PULLDOWN_N_R 0.07466f
C2423 PAD_P PULLDOWN_P_R 2.92129f
C2424 PAD_P DIV_ENABLE 0.14682f
C2425 PULLUP_P_BLEED_5 HS_N_10 0.02441f
C2426 TERM_OR_N_NS FS_LOW_P 0.12663f
C2427 PULLUP_P_BLEED_5 PULLDOWN_P 0
C2428 TERM_GATE_N_BLEED_0 TERM_VCM 0.04263f
C2429 a_43813_117064# ESD_RAIL 5.25092f
C2430 FS_N_BLEED_4 PULLUP_P 0.05445f
C2431 HS_P_9 PULLDOWN_P_R 0.07466f
C2432 FS_N_BLEED_0 FS_HIGH_N 0.32903f
C2433 TERM_GATE_N_BLEED_0 PULLDOWN_P 0.04828f
C2434 HS_N_6 HS_N_8 0.04151f
C2435 TERM_GATE_N_BLEED_0 HS_N_10 0.03489f
C2436 HS_P_2 HS_PBIAS 3.95109f
C2437 HS_N_0 FS_LOW_P 0.08516f
C2438 HS_P_13 HS_P 0.71007f
C2439 HS_N_2 PAD_P 1.25659f
C2440 PAD_P HS_P_11 1.25724f
C2441 FS_LOW_P FS_N_WELL 1.46004f
C2442 TERM_GATE_P HS_P_0 0.25837f
C2443 PULLUP_N_WELL HS_PBIAS 0.42834f
C2444 PULLUP_P_WELL VDD 30.3758f
C2445 PULLUP_P_CONTROL_S PULLUP_P_BLEED_0 0.00275f
C2446 FS_N_OUT TERM_GATE_P 0.1125f
C2447 FS_N_GATE VDD 23.571f
C2448 HS_P_11 HS_P_9 0.00817f
C2449 FS_P_WELL FS_LOW_P 1.90293f
C2450 PULLUP_P_BLEED_5 HS_N_8 0.04243f
C2451 TERM_OR_N_B TERM_N_R 5.91987f
C2452 PULLUP_N_BLEED_2 PULLUP_N_WELL 0.00114f
C2453 HS_N_9 VCM_LOW_OK 0.05893f
C2454 TERM_GATE_N_BLEED_0 HS_N_8 0.03489f
C2455 FS_P_OUT FS_HIGH_P 0.13265f
C2456 HS_N_4 PULLDOWN_P_R 0.02404f
C2457 HS_N_6 TERM_GATE_N_BLEED_2 0.03334f
C2458 HS_N_4 DIV_ENABLE 0.03089f
C2459 TERM_P_R HS_P_2 0.08491f
C2460 TERM_P_R PULLUP_N_WELL 0.29516f
C2461 PULLUP_P_BLEED_3 PULLDOWN_P_R 0.05462f
C2462 TERM_GATE_N_BLEED_1 TERM_GATE_N 0.42775f
C2463 FS_N_OUT RX_N 0.01566f
C2464 FS_P_OUT PULLDOWN_N_R 0.68986f
C2465 FS_P_BLEED_2 HS_N_0 0
C2466 PULLUP_P_BLEED_3 DIV_ENABLE 0.01375f
C2467 PULLDOWN_N DIFF_ENABLE 0.37137f
C2468 FS_P_BLEED_6 HS_N_13 0.06178f
C2469 a_41005_131545# ESD_RAIL 97.1325f
C2470 FS_P_GATE FS_LOW_P 0.55919f
C2471 FS_N_OUT TERM_GATE_N 0.05082f
C2472 PULLUP_P_GATE PULLUP_P 5.95692f
C2473 HS_N_11 PULLDOWN_P_R 0.02429f
C2474 FS_N_BLEED_0 HS_PBIAS 0.10276f
C2475 HS_N_2 HS_N_4 0.00206f
C2476 FS_N_GATE FS_LOW_N 0.75021f
C2477 TERM_N_R HS_N_5 0.05893f
C2478 HS_N_11 DIV_ENABLE 0.03161f
C2479 FS_P_WELL FS_P_BLEED_2 0.00213f
C2480 FS_N_BLEED_1 FS_N_BLEED_2 6.33216f
C2481 HS_N_4 HS_P_11 0.06606f
C2482 FS_P_BLEED_3 PULLUP_P_WELL 0
C2483 FS_P_OUT PAD_P 5.92309f
C2484 HS_N_6 PULLUP_P_BLEED_6 0
C2485 HS_N_9 HS_P 0.12097p
C2486 TERM_GATE_N_BLEED_2 TERM_GATE_N_BLEED_0 0.00153f
C2487 HS_N_2 PULLUP_P_BLEED_3 0.03489f
C2488 PULLUP_P_OUT TERM_OR_P_NS 0.1011f
C2489 FS_N_BLEED_3 TERM_VCM 0.13759f
C2490 FS_N_BLEED_3 PULLDOWN_P 0.08856f
C2491 FS_N_BLEED_4 PULLUP_N_WELL 0.01353f
C2492 HS_P_13 FS_LOW_P 0.04601f
C2493 HS_N_2 HS_N_11 0.0256f
C2494 HS_N_11 HS_P_11 0.06806f
C2495 FS_N_OUT FS_P_CONTROL_S 0.00663f
C2496 VDD FS_HIGH_P 0.65349f
C2497 TERM_N_R TERM_GATE_P_BLEED_0 0.14463f
C2498 FS_P_BLEED_2 FS_P_GATE 0.11441f
C2499 TERM_GATE_P_BLEED_2 TERM_OR_P_B 0.00349f
C2500 PULLUP_N_BLEED_6 DIV_ENABLE 0.03269f
C2501 TERM_GATE_P_BLEED_1 PULLDOWN_N_R 0.00195f
C2502 HS_P_7 HS_P_4 0.06067f
C2503 HS_N_13 HS_P_6 0.05888f
C2504 HS_N_7 FS_P_BLEED_5 0.06178f
C2505 FS_P_BLEED_0 HS_N 0.07763f
C2506 TERM_GATE_P PULLDOWN_P_R 0.30143f
C2507 VCM_LOW_OK HS_N_1 0.05893f
C2508 PULLUP_P_BLEED_5 PULLUP_P_BLEED_6 3.1342f
C2509 VDD PULLDOWN_N_R 2.95843f
C2510 DIV_N PULLUP_P_CONTROL_S 0.06087f
C2511 HS_P_12 HS_P_4 0
C2512 TERM_GATE_P DIV_ENABLE 0.00432f
C2513 DIV_N TERM_OR_P_B 0.00135f
C2514 PULLUP_N_BLEED_6 DIFF_ENABLE 0.35616f
C2515 HS_N_3 HS_P_12 0.03489f
C2516 PULLUP_N_OUT FS_P_BLEED_0 0.11535f
C2517 PULLUP_P_OUT PAD_N 0.20908f
C2518 PULLUP_N_GATE FS_HIGH_P 0.01763f
C2519 PULLDOWN_N_R HS_P_5 0.02411f
C2520 HS_N_7 HS_P_10 0
C2521 HS_N_6 HS_N_13 0.08101f
C2522 FS_P_OUT HS_N_4 0.43331f
C2523 TERM_VCM HS_P_7 0.11665f
C2524 HS_N_2 TERM_GATE_P 0.10747f
C2525 PAD_P VDD 0
C2526 FS_P_BLEED_5 HS_N_12 0.06178f
C2527 HS_N_10 HS_P_12 0.07709f
C2528 TERM_GATE_P HS_P_11 0.1736f
C2529 HS_P_12 TERM_VCM 0.107f
C2530 FS_N_BLEED_4 FS_N_BLEED_0 0.00763f
C2531 FS_LOW_N FS_HIGH_P 93.2199f
C2532 HS_N HS_P_4 0.15877f
C2533 PULLUP_N_GATE PULLDOWN_N_R 0.15922f
C2534 RX_N DIV_ENABLE 0.7437f
C2535 TERM_OR_N_S PULLDOWN_N_R 0.08196f
C2536 FS_P_BLEED_6 PULLUP_P_WELL 0.01133f
C2537 HS_P_8 HS_P_4 0.0312f
C2538 HS_N_3 HS_N 2.40305f
C2539 VDD HS_P_9 6.02581f
C2540 HS_P_3 HS_P_10 0.02866f
C2541 FS_LOW_N PULLDOWN_N_R 0.05849f
C2542 HS_P HS_N_1 0.13598f
C2543 TERM_GATE_N DIV_ENABLE 0.02173f
C2544 PAD_P HS_P_5 1.15443f
C2545 DIV_LOW_N HS_N 0.08856f
C2546 PULLUP_N_OUT HS_P_4 0.0863f
C2547 HS_N_9 FS_LOW_P 0.08576f
C2548 FS_P_BLEED_0 TERM_ENABLE 0.11038f
C2549 FS_P_OUT HS_N_11 0.43976f
C2550 TERM_OR_N_B VCM_LOW_OK 2.86687f
C2551 PULLUP_N_OUT HS_N_3 0.00232f
C2552 PULLUP_N_CONTROL_S VDD 0.68736f
C2553 FS_N_OUT DIV_P 2.20134f
C2554 TERM_GATE_N_BLEED_1 PULLUP_P 0.09196f
C2555 HS_P_1 PULLDOWN_N_R 0.06544f
C2556 HS_N_12 HS_P_10 0.04371f
C2557 HS_N_13 PULLUP_P_BLEED_5 0.02404f
C2558 FS_N_OUT PULLUP_P 0.52603f
C2559 PULLUP_N_OUT DIV_LOW_N 0.10124f
C2560 DIV_LOW_P HS_N_1 0.00376f
C2561 HS_N_10 HS_N 3.58671f
C2562 HS_P_9 HS_P_5 0
C2563 HS_N TERM_VCM 0.21341f
C2564 TERM_GATE_N_BLEED_0 HS_N_13 0.03489f
C2565 HS_N_2 TERM_GATE_N 0.04808f
C2566 HS_P_7 HS_N_8 0.09182f
C2567 HS_P_12 HS_N_8 0.06335f
C2568 TERM_VCM HS_P_8 0.09675f
C2569 PULLUP_N_BLEED_2 PULLUP_N_BLEED_3 0.39425f
C2570 PULLUP_N_OUT TERM_VCM 0.50835f
C2571 PULLUP_N_OUT PULLDOWN_P 0.10073f
C2572 ATB_ESD_RAIL VSS 0.86326f
C2573 RX_N VSS 44.4745f
C2574 RX_P VSS 43.7342f
C2575 BYPASS_ENABLE VSS 60.3857f
C2576 HS_N VSS 56.645f
C2577 HS_P VSS 40.6501f
C2578 PAD_P VSS 0.37048p
C2579 PAD_N VSS 0.36624p
C2580 FS_LOW_P VSS 38.0085f
C2581 TERM_ENABLE VSS 51.3239f
C2582 DIV_ENABLE VSS 22.9277f
C2583 TERM_VCM VSS 0.11353p
C2584 HS_PBIAS VSS 49.4032f
C2585 FS_HIGH_P VSS 8.62107f
C2586 PULLUP_P VSS 19.459f
C2587 PULLDOWN_P VSS 14.2957f
C2588 FS_LOW_N VSS 8.47881f
C2589 FS_HIGH_N VSS 4.29973f
C2590 PULLUP_N VSS 3.12827f
C2591 DIFF_ENABLE VSS 21.3621f
C2592 PULLDOWN_N VSS 4.99637f
C2593 ESD_RAIL VSS 2928.715664f
C2594 VDD VSS 0.72412p
C2595 m2_42279_124800# VSS 7.46506f $ **FLOATING
C2596 a_42245_90628# VSS 0.24972p
C2597 a_44789_117064# VSS 8.91806f
C2598 a_43813_117064# VSS 5.17875f
C2599 TERM_OR_P_S VSS 3.53275f
C2600 TERM_OR_P_NS VSS 10.064f
C2601 a_41005_131545# VSS 98.15211f
C2602 a_53878_131545# VSS 0.07835f
C2603 a_41005_131825# VSS 0.07377f
C2604 a_53878_132105# VSS 0.07394f
C2605 a_41005_132385# VSS 0.07377f
C2606 a_53878_132665# VSS 0.07394f
C2607 a_41005_132945# VSS 0.07377f
C2608 a_53878_133225# VSS 0.07394f
C2609 a_41005_133505# VSS 0.07377f
C2610 a_53878_133785# VSS 0.07394f
C2611 a_41005_134065# VSS 0.07377f
C2612 TERM_GATE_P_BLEED_2 VSS 3.28565f
C2613 TERM_GATE_P_BLEED_1 VSS 5.10072f
C2614 TERM_GATE_P_BLEED_0 VSS 7.68181f
C2615 TERM_OR_P_B VSS 21.1533f
C2616 a_53878_134345# VSS 0.07838f
C2617 TERM_GATE_P VSS 27.0289f
C2618 HS_P_4 VSS 7.08828f
C2619 HS_P_3 VSS 7.10742f
C2620 HS_P_2 VSS 6.92881f
C2621 HS_P_1 VSS 5.64833f
C2622 HS_P_0 VSS 7.04643f
C2623 DIV_LOW_P VSS 7.23693f
C2624 DIV_P VSS 14.1199f
C2625 HS_P_11 VSS 8.66739f
C2626 HS_P_10 VSS 6.56271f
C2627 HS_P_9 VSS 7.07186f
C2628 HS_P_8 VSS 5.68784f
C2629 HS_P_7 VSS 4.83585f
C2630 HS_P_6 VSS 5.96193f
C2631 HS_P_5 VSS 7.82827f
C2632 HS_P_13 VSS 6.1434f
C2633 HS_P_12 VSS 7.62117f
C2634 a_41852_148519# VSS 0.41778p
C2635 FS_P_BLEED_0 VSS 5.25478f
C2636 FS_P_CONTROL_S VSS 4.50476f
C2637 FS_P_OUT VSS 33.2921f
C2638 FS_P_GATE VSS 50.584f
C2639 FS_P_BLEED_6 VSS 4.71981f
C2640 FS_P_BLEED_5 VSS 4.09514f
C2641 FS_P_BLEED_4 VSS 3.52334f
C2642 FS_P_BLEED_3 VSS 3.16733f
C2643 FS_P_BLEED_2 VSS 3.71625f
C2644 FS_P_BLEED_1 VSS 8.07846f
C2645 PULLUP_P_OUT VSS 22.0369f
C2646 PULLUP_P_BLEED_2 VSS 4.21729f
C2647 PULLUP_P_BLEED_1 VSS 3.22052f
C2648 PULLUP_P_BLEED_0 VSS 3.1427f
C2649 PULLUP_P_CONTROL_S VSS 14.2222f
C2650 PULLDOWN_P_R VSS 21.8133f
C2651 PULLUP_P_GATE VSS 18.622f
C2652 PULLUP_P_BLEED_6 VSS 5.9721f
C2653 PULLUP_P_BLEED_5 VSS 8.83533f
C2654 PULLUP_P_BLEED_4 VSS 11.7853f
C2655 PULLUP_P_BLEED_3 VSS 8.31118f
C2656 TERM_OR_N_B VSS 9.20695f
C2657 TERM_OR_N_S VSS 8.30319f
C2658 TERM_OR_N_NS VSS 5.94472f
C2659 VCM_LOW_OK VSS 25.8357f
C2660 TERM_GATE_N_BLEED_2 VSS 14.3664f
C2661 TERM_GATE_N_BLEED_1 VSS 13.4026f
C2662 TERM_GATE_N_BLEED_0 VSS 8.30278f
C2663 HS_N_0 VSS 11.8194f
C2664 DIV_LOW_N VSS 8.79168f
C2665 DIV_N VSS 18.8798f
C2666 TERM_GATE_N VSS 18.495f
C2667 HS_N_7 VSS 9.28359f
C2668 HS_N_6 VSS 9.29898f
C2669 HS_N_5 VSS 8.48041f
C2670 HS_N_4 VSS 7.55183f
C2671 HS_N_3 VSS 7.91514f
C2672 HS_N_2 VSS 8.95462f
C2673 HS_N_1 VSS 9.59159f
C2674 HS_N_13 VSS 9.06212f
C2675 HS_N_12 VSS 9.99856f
C2676 HS_N_11 VSS 9.36849f
C2677 HS_N_10 VSS 9.03359f
C2678 HS_N_9 VSS 8.5391f
C2679 HS_N_8 VSS 9.00333f
C2680 FS_N_CONTROL_S VSS 6.67541f
C2681 FS_N_OUT VSS 66.0491f
C2682 FS_N_BLEED_3 VSS 5.83837f
C2683 FS_N_BLEED_2 VSS 4.75153f
C2684 FS_N_BLEED_1 VSS 4.13355f
C2685 FS_N_BLEED_0 VSS 3.57892f
C2686 FS_N_GATE VSS 51.2723f
C2687 FS_N_BLEED_6 VSS 3.35184f
C2688 FS_N_BLEED_5 VSS 3.45768f
C2689 FS_N_BLEED_4 VSS 8.08501f
C2690 PULLUP_N_CONTROL_S VSS 4.4075f
C2691 PULLUP_N_OUT VSS 44.4704f
C2692 PULLUP_N_BLEED_5 VSS 4.51663f
C2693 PULLUP_N_BLEED_4 VSS 3.53996f
C2694 PULLUP_N_BLEED_3 VSS 2.95235f
C2695 PULLUP_N_BLEED_2 VSS 3.88779f
C2696 PULLUP_N_BLEED_1 VSS 6.69252f
C2697 PULLUP_N_BLEED_0 VSS 9.62445f
C2698 TERM_P_R VSS 90.06779f
C2699 TERM_N_R VSS 0.10882p
C2700 PULLDOWN_N_R VSS 36.5261f
C2701 PULLUP_N_GATE VSS 18.208f
C2702 PULLUP_N_BLEED_6 VSS 8.22239f
C2703 FS_P_WELL VSS 0.43173p
C2704 PULLUP_P_WELL VSS 97.9489f
C2705 FS_N_WELL VSS 0.43826p
C2706 PULLUP_N_WELL VSS 0.10052p
DWELL_ARRAY VSS ESD_RAIL diode_nw2ps_06v0 area=569.4528p pj=470.72u
.ends

.lib /home/ubuntu/svalbard/scratch/transceiver-pad-pdk/ngspice/sm141064.ngspice diode_typical
.lib /home/ubuntu/svalbard/scratch/transceiver-pad-pdk/ngspice/sm141064.ngspice mimcap_typical
