.subckt tx_protected_pad PAD_P PAD_N VDD VSS TERM_VCM TERM_ENABLE DIFF_ENABLE DIV_ENABLE BYPASS_ENABLE RX_P RX_N HS_PBIAS HS_P HS_N FS_HIGH_P FS_HIGH_N FS_LOW_P FS_LOW_N PULLUP_P PULLUP_N PULLDOWN_P PULLDOWN_N ATB_ESD_RAIL
XPHYSICAL PAD_P PAD_N VDD VSS TERM_VCM TERM_ENABLE DIFF_ENABLE DIV_ENABLE BYPASS_ENABLE RX_P RX_N HS_PBIAS HS_P HS_N FS_HIGH_P FS_HIGH_N FS_LOW_P FS_LOW_N PULLUP_P PULLUP_N PULLDOWN_P PULLDOWN_N ESD_RAIL ATB_ESD_RAIL combined_flat
.ends tx_protected_pad
* NGSPICE file created from combined_flat.ext - technology: gf180mcuD

.subckt combined_flat PAD_P PAD_N VDD VSS TERM_VCM TERM_ENABLE DIFF_ENABLE DIV_ENABLE
+ BYPASS_ENABLE RX_P RX_N HS_PBIAS HS_P HS_N FS_HIGH_P FS_HIGH_N FS_LOW_P FS_LOW_N
+ PULLUP_P PULLUP_N PULLDOWN_P PULLDOWN_N ESD_RAIL ATB_ESD_RAIL
X0 a_41684_232275# a_41684_232275# VSS VSS nfet_06v0 ad=13p pd=50.52u as=13p ps=50.52u w=50u l=0.7u
X1 a_41684_220611# a_41684_220611# a_41684_232275# VSS nfet_06v0 ad=13p pd=50.52u as=13p ps=50.52u w=50u l=0.7u
X2 ESD_RAIL ESD_RAIL a_41684_220611# VSS nfet_06v0 ad=13p pd=50.52u as=13p ps=50.52u w=50u l=0.7u
X3 a_41684_220611# ESD_RAIL ESD_RAIL VSS nfet_06v0 ad=13p pd=50.52u as=13p ps=50.52u w=50u l=0.7u
X4 ESD_RAIL a_42245_162628# VSS VSS nfet_06v0 ad=13p pd=50.52u as=13p ps=50.52u w=50u l=0.7u
X5 a_41684_220611# ESD_RAIL ESD_RAIL VSS nfet_06v0 ad=13p pd=50.52u as=13p ps=50.52u w=50u l=0.7u
X6 ESD_RAIL ESD_RAIL a_41684_220611# VSS nfet_06v0 ad=13p pd=50.52u as=13p ps=50.52u w=50u l=0.7u
X7 VSS a_41684_232275# a_41684_232275# VSS nfet_06v0 ad=13p pd=50.52u as=13p ps=50.52u w=50u l=0.7u
X8 a_41684_232275# a_41684_220611# a_41684_220611# VSS nfet_06v0 ad=13p pd=50.52u as=13p ps=50.52u w=50u l=0.7u
X9 FS_N_OUT FS_N_GATE FS_N_WELL FS_N_WELL pfet_03v3 ad=6.16p pd=28.88u as=6.16p ps=28.88u w=14u l=0.28u
X10 a_41684_220611# a_41684_220611# a_41684_232275# VSS nfet_06v0 ad=13p pd=50.52u as=13p ps=50.52u w=50u l=0.7u
X11 ESD_RAIL ESD_RAIL a_41684_220611# VSS nfet_06v0 ad=13p pd=50.52u as=13p ps=50.52u w=50u l=0.7u
X12 ESD_RAIL a_44789_189064# a_42245_162628# ESD_RAIL pfet_06v0 ad=1.3p pd=5.52u as=1.3p ps=5.52u w=5u l=0.7u
X13 a_41684_220611# ESD_RAIL ESD_RAIL VSS nfet_06v0 ad=22p pd=0.10088m as=13p ps=50.52u w=50u l=0.7u
X14 TERM_P_R TERM_GATE_P TERM_VCM VSS nfet_03v3 ad=8.8p pd=40.88u as=8.8p ps=40.88u w=20u l=0.28u
X15 ESD_RAIL a_42245_162628# VSS VSS nfet_06v0 ad=13p pd=50.52u as=13p ps=50.52u w=50u l=0.7u
X16 a_41684_220611# ESD_RAIL ESD_RAIL VSS nfet_06v0 ad=13p pd=50.52u as=13p ps=50.52u w=50u l=0.7u
X17 a_41684_220611# ESD_RAIL ESD_RAIL VSS nfet_06v0 ad=13p pd=50.52u as=13p ps=50.52u w=50u l=0.7u
X18 a_41684_220611# a_41684_220611# a_41684_232275# VSS nfet_06v0 ad=13p pd=50.52u as=13p ps=50.52u w=50u l=0.7u
X19 a_41684_232275# a_41684_220611# a_41684_220611# VSS nfet_06v0 ad=13p pd=50.52u as=13p ps=50.52u w=50u l=0.7u
X20 ESD_RAIL ESD_RAIL a_41684_220611# VSS nfet_06v0 ad=13p pd=50.52u as=13p ps=50.52u w=50u l=0.7u
X21 HS_N_5 HS_N PAD_N VSS nfet_06v0 ad=8.8p pd=40.88u as=8.8p ps=40.88u w=20u l=0.7u
D0 VSS PAD_N diode_nd2ps_06v0 pj=51.8u area=22.5p
X22 VSS a_41684_232275# a_41684_232275# VSS nfet_06v0 ad=13p pd=50.52u as=13p ps=50.52u w=50u l=0.7u
X23 a_41684_220611# ESD_RAIL ESD_RAIL VSS nfet_06v0 ad=13p pd=50.52u as=13p ps=50.52u w=50u l=0.7u
X24 TERM_GATE_P TERM_GATE_P_BLEED_0 VSS ppolyf_u_1k r_width=1u r_length=12.5u
X25 ESD_RAIL ESD_RAIL a_41684_220611# VSS nfet_06v0 ad=13p pd=50.52u as=13p ps=50.52u w=50u l=0.7u
X26 a_41684_220611# ESD_RAIL ESD_RAIL VSS nfet_06v0 ad=13p pd=50.52u as=13p ps=50.52u w=50u l=0.7u
X27 ESD_RAIL ESD_RAIL a_41684_220611# VSS nfet_06v0 ad=13p pd=50.52u as=13p ps=50.52u w=50u l=0.7u
X28 a_41684_220611# ESD_RAIL ESD_RAIL VSS nfet_06v0 ad=13p pd=50.52u as=13p ps=50.52u w=50u l=0.7u
X29 FS_P_GATE FS_HIGH_P FS_P_WELL FS_P_WELL pfet_03v3 ad=1.76p pd=8.88u as=1.76p ps=8.88u w=4u l=0.28u
X30 a_41684_232275# a_41684_232275# VSS VSS nfet_06v0 ad=13p pd=50.52u as=13p ps=50.52u w=50u l=0.7u
X31 a_41684_220611# a_41684_220611# a_41684_232275# VSS nfet_06v0 ad=13p pd=50.52u as=13p ps=50.52u w=50u l=0.7u
X32 a_41684_232275# a_41684_220611# a_41684_220611# VSS nfet_06v0 ad=13p pd=50.52u as=13p ps=50.52u w=50u l=0.7u
X33 ESD_RAIL ESD_RAIL a_41684_220611# VSS nfet_06v0 ad=13p pd=50.52u as=13p ps=50.52u w=50u l=0.7u
X34 a_41684_220611# ESD_RAIL ESD_RAIL VSS nfet_06v0 ad=13p pd=50.52u as=13p ps=50.52u w=50u l=0.7u
X35 a_41684_232275# a_41684_220611# a_41684_220611# VSS nfet_06v0 ad=13p pd=50.52u as=13p ps=50.52u w=50u l=0.7u
X36 ESD_RAIL ESD_RAIL a_41684_220611# VSS nfet_06v0 ad=13p pd=50.52u as=13p ps=50.52u w=50u l=0.7u
X37 FS_P_CONTROL_S VDD VSS VSS nfet_03v3 ad=1.76p pd=8.88u as=1.76p ps=8.88u w=4u l=0.28u
X38 a_41684_220611# a_41684_220611# a_41684_232275# VSS nfet_06v0 ad=13p pd=50.52u as=13p ps=50.52u w=50u l=0.7u
X39 a_41684_232275# a_41684_220611# a_41684_220611# VSS nfet_06v0 ad=13p pd=50.52u as=13p ps=50.52u w=50u l=0.7u
X40 a_41684_220611# a_41684_220611# a_41684_232275# VSS nfet_06v0 ad=13p pd=50.52u as=13p ps=50.52u w=50u l=0.7u
X41 a_41684_220611# a_41684_220611# a_41684_232275# VSS nfet_06v0 ad=13p pd=50.52u as=13p ps=50.52u w=50u l=0.7u
X42 a_41684_220611# ESD_RAIL ESD_RAIL VSS nfet_06v0 ad=13p pd=50.52u as=13p ps=50.52u w=50u l=0.7u
X43 HS_P_4 HS_PBIAS VDD VDD pfet_03v3 ad=8.8p pd=40.88u as=8.8p ps=40.88u w=20u l=1u
X44 ESD_RAIL ESD_RAIL a_41684_220611# VSS nfet_06v0 ad=13p pd=50.52u as=13p ps=50.52u w=50u l=0.7u
X45 ESD_RAIL ESD_RAIL a_41684_220611# VSS nfet_06v0 ad=13p pd=50.52u as=13p ps=50.52u w=50u l=0.7u
X46 PULLUP_N_BLEED_6 PULLUP_N_GATE VSS ppolyf_u_1k r_width=1u r_length=12.5u
X47 a_41684_232275# a_41684_220611# a_41684_220611# VSS nfet_06v0 ad=13p pd=50.52u as=13p ps=50.52u w=50u l=0.7u
X48 a_41684_220611# a_41684_220611# a_41684_232275# VSS nfet_06v0 ad=13p pd=50.52u as=13p ps=50.52u w=50u l=0.7u
X49 TERM_N_R TERM_GATE_N TERM_VCM VSS nfet_03v3 ad=8.8p pd=40.88u as=8.8p ps=40.88u w=20u l=0.28u
X50 a_41684_220611# a_41684_220611# a_41684_232275# VSS nfet_06v0 ad=13p pd=50.52u as=13p ps=50.52u w=50u l=0.7u
X51 a_41684_220611# ESD_RAIL ESD_RAIL VSS nfet_06v0 ad=13p pd=50.52u as=13p ps=50.52u w=50u l=0.7u
X52 VSS a_42245_162628# ESD_RAIL VSS nfet_06v0 ad=13p pd=50.52u as=22p ps=0.10088m w=50u l=0.7u
X53 ESD_RAIL ESD_RAIL a_41684_220611# VSS nfet_06v0 ad=13p pd=50.52u as=13p ps=50.52u w=50u l=0.7u
X54 ESD_RAIL ESD_RAIL a_41684_220611# VSS nfet_06v0 ad=13p pd=50.52u as=13p ps=50.52u w=50u l=0.7u
X55 a_41684_220611# ESD_RAIL ESD_RAIL VSS nfet_06v0 ad=13p pd=50.52u as=13p ps=50.52u w=50u l=0.7u
X56 TERM_P_R TERM_GATE_P TERM_VCM VSS nfet_03v3 ad=8.8p pd=40.88u as=8.8p ps=40.88u w=20u l=0.28u
X57 PULLUP_P_CONTROL_S VDD VSS VSS nfet_03v3 ad=1.76p pd=8.88u as=1.76p ps=8.88u w=4u l=0.28u
X58 a_41684_232275# a_41684_220611# a_41684_220611# VSS nfet_06v0 ad=13p pd=50.52u as=13p ps=50.52u w=50u l=0.7u
X59 a_41684_220611# a_41684_220611# a_41684_232275# VSS nfet_06v0 ad=13p pd=50.52u as=13p ps=50.52u w=50u l=0.7u
X60 a_41684_220611# a_41684_220611# a_41684_232275# VSS nfet_06v0 ad=13p pd=50.52u as=13p ps=50.52u w=50u l=0.7u
X61 ESD_RAIL ESD_RAIL a_41684_220611# VSS nfet_06v0 ad=13p pd=50.52u as=13p ps=50.52u w=50u l=0.7u
X62 VSS a_42245_162628# ESD_RAIL VSS nfet_06v0 ad=13p pd=50.52u as=13p ps=50.52u w=50u l=0.7u
X63 VDD FS_P_GATE FS_P_WELL FS_P_WELL pfet_03v3 ad=6.16p pd=28.88u as=6.16p ps=28.88u w=14u l=0.28u
X64 PULLUP_N_OUT PULLUP_N_GATE PULLUP_N_WELL PULLUP_N_WELL pfet_03v3 ad=8.8p pd=40.88u as=8.8p ps=40.88u w=20u l=0.28u
X65 TERM_N_R TERM_GATE_N TERM_VCM VSS nfet_03v3 ad=8.8p pd=40.88u as=8.8p ps=40.88u w=20u l=0.28u
X66 HS_N_4 HS_N PAD_N VSS nfet_06v0 ad=8.8p pd=40.88u as=8.8p ps=40.88u w=20u l=0.7u
X67 ESD_RAIL a_42245_162628# VSS VSS nfet_06v0 ad=22p pd=0.10088m as=13p ps=50.52u w=50u l=0.7u
X68 a_41684_232275# a_41684_220611# a_41684_220611# VSS nfet_06v0 ad=13p pd=50.52u as=13p ps=50.52u w=50u l=0.7u
X69 a_41684_220611# a_41684_220611# a_41684_232275# VSS nfet_06v0 ad=13p pd=50.52u as=13p ps=50.52u w=50u l=0.7u
X70 a_41684_220611# ESD_RAIL ESD_RAIL VSS nfet_06v0 ad=13p pd=50.52u as=13p ps=50.52u w=50u l=0.7u
D1 VSS PAD_P diode_nd2ps_06v0 pj=51.8u area=22.5p
X71 ESD_RAIL a_42245_162628# VSS VSS nfet_06v0 ad=13p pd=50.52u as=13p ps=50.52u w=50u l=0.7u
X72 a_41684_232275# a_41684_220611# a_41684_220611# VSS nfet_06v0 ad=13p pd=50.52u as=13p ps=50.52u w=50u l=0.7u
X73 VDD FS_P_GATE FS_P_WELL FS_P_WELL pfet_03v3 ad=6.16p pd=28.88u as=6.16p ps=28.88u w=14u l=0.28u
X74 ESD_RAIL ESD_RAIL a_41684_220611# VSS nfet_06v0 ad=13p pd=50.52u as=13p ps=50.52u w=50u l=0.7u
X75 PULLUP_N_OUT PULLUP_N_GATE PULLUP_N_WELL PULLUP_N_WELL pfet_03v3 ad=8.8p pd=40.88u as=8.8p ps=40.88u w=20u l=0.28u
X76 VDD FS_N_GATE FS_N_WELL FS_N_WELL pfet_03v3 ad=6.16p pd=28.88u as=6.16p ps=28.88u w=14u l=0.28u
X77 a_41684_220611# a_41684_220611# a_41684_232275# VSS nfet_06v0 ad=13p pd=50.52u as=13p ps=50.52u w=50u l=0.7u
X78 a_41684_220611# ESD_RAIL ESD_RAIL VSS nfet_06v0 ad=13p pd=50.52u as=13p ps=50.52u w=50u l=0.7u
X79 a_41684_220611# ESD_RAIL ESD_RAIL VSS nfet_06v0 ad=13p pd=50.52u as=13p ps=50.52u w=50u l=0.7u
X80 VSS a_41684_232275# a_41684_232275# VSS nfet_06v0 ad=13p pd=50.52u as=13p ps=50.52u w=50u l=0.7u
X81 a_41684_220611# a_41684_220611# a_41684_232275# VSS nfet_06v0 ad=13p pd=50.52u as=13p ps=50.52u w=50u l=0.7u
X82 FS_N_GATE VDD FS_N_WELL FS_N_WELL pfet_03v3 ad=1.76p pd=8.88u as=1.76p ps=8.88u w=4u l=0.28u
X83 a_41684_232275# a_41684_220611# a_41684_220611# VSS nfet_06v0 ad=13p pd=50.52u as=13p ps=50.52u w=50u l=0.7u
X84 VDD FS_N_GATE FS_N_WELL FS_N_WELL pfet_03v3 ad=6.16p pd=28.88u as=6.16p ps=28.88u w=14u l=0.28u
X85 ESD_RAIL ESD_RAIL a_41684_220611# VSS nfet_06v0 ad=13p pd=50.52u as=13p ps=50.52u w=50u l=0.7u
X86 FS_P_OUT FS_P_GATE FS_P_WELL FS_P_WELL pfet_03v3 ad=6.16p pd=28.88u as=6.16p ps=28.88u w=14u l=0.28u
X87 a_41684_220611# ESD_RAIL ESD_RAIL VSS nfet_06v0 ad=13p pd=50.52u as=13p ps=50.52u w=50u l=0.7u
X88 a_41684_220611# ESD_RAIL ESD_RAIL VSS nfet_06v0 ad=13p pd=50.52u as=13p ps=50.52u w=50u l=0.7u
X89 TERM_OR_N_S TERM_ENABLE VDD VDD pfet_03v3 ad=1.76p pd=8.88u as=1.76p ps=8.88u w=4u l=0.28u
X90 PULLUP_P_BLEED_1 PULLUP_P_BLEED_2 VSS ppolyf_u_1k r_width=1u r_length=12.5u
X91 a_41684_220611# a_41684_220611# a_41684_232275# VSS nfet_06v0 ad=13p pd=50.52u as=13p ps=50.52u w=50u l=0.7u
X92 a_41684_232275# a_41684_232275# VSS VSS nfet_06v0 ad=13p pd=50.52u as=13p ps=50.52u w=50u l=0.7u
X93 a_41684_220611# ESD_RAIL ESD_RAIL VSS nfet_06v0 ad=13p pd=50.52u as=13p ps=50.52u w=50u l=0.7u
X94 a_41684_232275# a_41684_220611# a_41684_220611# VSS nfet_06v0 ad=13p pd=50.52u as=13p ps=50.52u w=50u l=0.7u
X95 a_41684_220611# a_41684_220611# a_41684_232275# VSS nfet_06v0 ad=13p pd=50.52u as=13p ps=50.52u w=50u l=0.7u
X96 PULLDOWN_P_R PULLDOWN_P VSS VSS nfet_03v3 ad=3.52p pd=16.88u as=3.52p ps=16.88u w=8u l=0.28u
X97 a_41684_232275# a_41684_232275# VSS VSS nfet_06v0 ad=13p pd=50.52u as=13p ps=50.52u w=50u l=0.7u
X98 a_41684_220611# ESD_RAIL ESD_RAIL VSS nfet_06v0 ad=13p pd=50.52u as=13p ps=50.52u w=50u l=0.7u
X99 a_41684_232275# a_41684_220611# a_41684_220611# VSS nfet_06v0 ad=13p pd=50.52u as=13p ps=50.52u w=50u l=0.7u
X100 VSS a_41684_232275# a_41684_232275# VSS nfet_06v0 ad=13p pd=50.52u as=13p ps=50.52u w=50u l=0.7u
X101 ESD_RAIL a_42245_162628# VSS VSS nfet_06v0 ad=13p pd=50.52u as=13p ps=50.52u w=50u l=0.7u
X102 a_41684_232275# a_41684_232275# VSS VSS nfet_06v0 ad=13p pd=50.52u as=13p ps=50.52u w=50u l=0.7u
X103 VSS a_41684_232275# a_41684_232275# VSS nfet_06v0 ad=13p pd=50.52u as=13p ps=50.52u w=50u l=0.7u
X104 a_41684_232275# a_41684_232275# VSS VSS nfet_06v0 ad=13p pd=50.52u as=13p ps=50.52u w=50u l=0.7u
X105 ESD_RAIL a_42245_162628# VSS VSS nfet_06v0 ad=13p pd=50.52u as=13p ps=50.52u w=50u l=0.7u
X106 ESD_RAIL a_41005_203545# a_43813_189064# ESD_RAIL pfet_06v0 ad=1.3p pd=5.52u as=1.3p ps=5.52u w=5u l=0.7u
X107 a_41684_232275# a_41684_220611# a_41684_220611# VSS nfet_06v0 ad=13p pd=50.52u as=13p ps=50.52u w=50u l=0.7u
X108 VSS a_41684_232275# a_41684_232275# VSS nfet_06v0 ad=13p pd=50.52u as=13p ps=50.52u w=50u l=0.7u
X109 a_41684_220611# a_41684_220611# a_41684_232275# VSS nfet_06v0 ad=13p pd=50.52u as=13p ps=50.52u w=50u l=0.7u
X110 VSS a_42245_162628# ESD_RAIL VSS nfet_06v0 ad=13p pd=50.52u as=13p ps=50.52u w=50u l=0.7u
X111 FS_P_OUT FS_P_GATE FS_P_WELL FS_P_WELL pfet_03v3 ad=6.16p pd=28.88u as=6.16p ps=28.88u w=14u l=0.28u
X112 ESD_RAIL ESD_RAIL a_41684_220611# VSS nfet_06v0 ad=13p pd=50.52u as=13p ps=50.52u w=50u l=0.7u
X113 a_41684_232275# a_41684_220611# a_41684_220611# VSS nfet_06v0 ad=13p pd=50.52u as=13p ps=50.52u w=50u l=0.7u
X114 VSS a_41684_232275# a_41684_232275# VSS nfet_06v0 ad=13p pd=50.52u as=13p ps=50.52u w=50u l=0.7u
X115 a_41684_220611# ESD_RAIL ESD_RAIL VSS nfet_06v0 ad=13p pd=50.52u as=13p ps=50.52u w=50u l=0.7u
X116 a_41684_232275# a_41684_232275# VSS VSS nfet_06v0 ad=13p pd=50.52u as=13p ps=50.52u w=50u l=0.7u
X117 a_41684_220611# a_41684_220611# a_41684_232275# VSS nfet_06v0 ad=13p pd=50.52u as=13p ps=50.52u w=50u l=0.7u
X118 ESD_RAIL ESD_RAIL a_41684_220611# VSS nfet_06v0 ad=13p pd=50.52u as=13p ps=50.52u w=50u l=0.7u
X119 HS_P_9 HS_PBIAS VDD VDD pfet_03v3 ad=8.8p pd=40.88u as=8.8p ps=40.88u w=20u l=1u
X120 a_41684_220611# ESD_RAIL ESD_RAIL VSS nfet_06v0 ad=13p pd=50.52u as=13p ps=50.52u w=50u l=0.7u
D2 VSS PAD_N diode_nd2ps_06v0 pj=51.8u area=22.5p
X121 VSS a_41684_232275# a_41684_232275# VSS nfet_06v0 ad=13p pd=50.52u as=13p ps=50.52u w=50u l=0.7u
X122 a_41684_232275# a_41684_232275# VSS VSS nfet_06v0 ad=13p pd=50.52u as=13p ps=50.52u w=50u l=0.7u
X123 a_42245_162628# a_44789_189064# ESD_RAIL ESD_RAIL pfet_06v0 ad=1.3p pd=5.52u as=1.3p ps=5.52u w=5u l=0.7u
X124 a_41684_232275# a_41684_232275# VSS VSS nfet_06v0 ad=13p pd=50.52u as=13p ps=50.52u w=50u l=0.7u
X125 FS_P_OUT FS_P_GATE FS_P_WELL FS_P_WELL pfet_03v3 ad=6.16p pd=28.88u as=6.16p ps=28.88u w=14u l=0.28u
X126 VDD FS_N_GATE FS_N_WELL FS_N_WELL pfet_03v3 ad=6.16p pd=28.88u as=6.16p ps=28.88u w=14u l=0.28u
X127 a_41684_232275# a_41684_220611# a_41684_220611# VSS nfet_06v0 ad=13p pd=50.52u as=13p ps=50.52u w=50u l=0.7u
X128 HS_N_9 HS_N PAD_N VSS nfet_06v0 ad=8.8p pd=40.88u as=8.8p ps=40.88u w=20u l=0.7u
X129 a_41684_220611# ESD_RAIL ESD_RAIL VSS nfet_06v0 ad=13p pd=50.52u as=13p ps=50.52u w=50u l=0.7u
X130 a_41684_220611# a_41684_220611# a_41684_232275# VSS nfet_06v0 ad=13p pd=50.52u as=13p ps=50.52u w=50u l=0.7u
X131 ESD_RAIL ESD_RAIL a_41684_220611# VSS nfet_06v0 ad=13p pd=50.52u as=13p ps=50.52u w=50u l=0.7u
X132 FS_P_OUT FS_P_GATE FS_P_WELL FS_P_WELL pfet_03v3 ad=6.16p pd=28.88u as=6.16p ps=28.88u w=14u l=0.28u
X133 a_41684_232275# a_41684_232275# VSS VSS nfet_06v0 ad=13p pd=50.52u as=13p ps=50.52u w=50u l=0.7u
X134 VSS a_41684_232275# a_41684_232275# VSS nfet_06v0 ad=13p pd=50.52u as=13p ps=50.52u w=50u l=0.7u
X135 a_41684_220611# ESD_RAIL ESD_RAIL VSS nfet_06v0 ad=13p pd=50.52u as=13p ps=50.52u w=50u l=0.7u
X136 VSS a_42245_162628# ESD_RAIL VSS nfet_06v0 ad=13p pd=50.52u as=13p ps=50.52u w=50u l=0.7u
X137 ESD_RAIL ESD_RAIL a_41684_220611# VSS nfet_06v0 ad=13p pd=50.52u as=13p ps=50.52u w=50u l=0.7u
X138 a_41684_220611# ESD_RAIL ESD_RAIL VSS nfet_06v0 ad=13p pd=50.52u as=13p ps=50.52u w=50u l=0.7u
X139 a_41005_204385# a_53878_204105# ESD_RAIL ppolyf_u r_width=0.8u r_length=63.855u
X140 ESD_RAIL ESD_RAIL a_41684_220611# VSS nfet_06v0 ad=13p pd=50.52u as=22p ps=0.10088m w=50u l=0.7u
X141 VSS a_41684_232275# a_41684_232275# VSS nfet_06v0 ad=13p pd=50.52u as=13p ps=50.52u w=50u l=0.7u
X142 a_41684_232275# a_41684_232275# VSS VSS nfet_06v0 ad=13p pd=50.52u as=13p ps=50.52u w=50u l=0.7u
X143 VSS a_41684_232275# a_41684_232275# VSS nfet_06v0 ad=13p pd=50.52u as=13p ps=50.52u w=50u l=0.7u
X144 a_41684_220611# a_41684_220611# a_41684_232275# VSS nfet_06v0 ad=13p pd=50.52u as=13p ps=50.52u w=50u l=0.7u
X145 ESD_RAIL a_42245_162628# VSS VSS nfet_06v0 ad=13p pd=50.52u as=13p ps=50.52u w=50u l=0.7u
X146 ESD_RAIL a_42245_162628# VSS VSS nfet_06v0 ad=13p pd=50.52u as=13p ps=50.52u w=50u l=0.7u
X147 HS_P_7 HS_PBIAS VDD VDD pfet_03v3 ad=8.8p pd=40.88u as=8.8p ps=40.88u w=20u l=1u
X148 a_41684_220611# ESD_RAIL ESD_RAIL VSS nfet_06v0 ad=13p pd=50.52u as=13p ps=50.52u w=50u l=0.7u
X149 VSS a_41684_232275# a_41684_232275# VSS nfet_06v0 ad=13p pd=50.52u as=13p ps=50.52u w=50u l=0.7u
X150 HS_P_11 HS_P PAD_P VSS nfet_06v0 ad=8.8p pd=40.88u as=8.8p ps=40.88u w=20u l=0.7u
X151 ESD_RAIL ESD_RAIL a_41684_220611# VSS nfet_06v0 ad=13p pd=50.52u as=13p ps=50.52u w=50u l=0.7u
X152 TERM_P_R TERM_GATE_P TERM_VCM VSS nfet_03v3 ad=8.8p pd=40.88u as=8.8p ps=40.88u w=20u l=0.28u
X153 PAD_P PULLDOWN_P_R VSS ppolyf_u_1k r_width=1u r_length=14.2u
D3 VSS PAD_P diode_nd2ps_06v0 pj=51.8u area=22.5p
X154 ESD_RAIL a_42245_162628# VSS VSS nfet_06v0 ad=13p pd=50.52u as=13p ps=50.52u w=50u l=0.7u
X155 ESD_RAIL ESD_RAIL a_41684_220611# VSS nfet_06v0 ad=13p pd=50.52u as=13p ps=50.52u w=50u l=0.7u
X156 ESD_RAIL a_42245_162628# VSS VSS nfet_06v0 ad=13p pd=50.52u as=13p ps=50.52u w=50u l=0.7u
X157 a_42245_162628# a_44789_189064# ESD_RAIL ESD_RAIL pfet_06v0 ad=1.3p pd=5.52u as=1.3p ps=5.52u w=5u l=0.7u
X158 a_41684_220611# ESD_RAIL ESD_RAIL VSS nfet_06v0 ad=13p pd=50.52u as=13p ps=50.52u w=50u l=0.7u
X159 PAD_P BYPASS_ENABLE RX_P VSS nfet_06v0 ad=8.8p pd=40.88u as=8.8p ps=40.88u w=20u l=0.7u
X160 VSS a_41684_232275# a_41684_232275# VSS nfet_06v0 ad=13p pd=50.52u as=13p ps=50.52u w=50u l=0.7u
X161 a_41684_232275# a_41684_232275# VSS VSS nfet_06v0 ad=13p pd=50.52u as=13p ps=50.52u w=50u l=0.7u
X162 ESD_RAIL ESD_RAIL a_41684_220611# VSS nfet_06v0 ad=13p pd=50.52u as=13p ps=50.52u w=50u l=0.7u
X163 HS_N_6 HS_N PAD_N VSS nfet_06v0 ad=8.8p pd=40.88u as=8.8p ps=40.88u w=20u l=0.7u
X164 VDD FS_N_GATE FS_N_WELL FS_N_WELL pfet_03v3 ad=6.16p pd=28.88u as=6.16p ps=28.88u w=14u l=0.28u
X165 FS_P_OUT FS_P_GATE FS_P_WELL FS_P_WELL pfet_03v3 ad=6.16p pd=28.88u as=6.16p ps=28.88u w=14u l=0.28u
D4 VSS ESD_RAIL diode_nd2ps_06v0 pj=82u area=40p
X166 ESD_RAIL ESD_RAIL a_41684_220611# VSS nfet_06v0 ad=13p pd=50.52u as=13p ps=50.52u w=50u l=0.7u
X167 DIV_LOW_P DIV_ENABLE VSS VSS nfet_03v3 ad=8.8p pd=40.88u as=8.8p ps=40.88u w=20u l=0.28u
X168 a_41684_232275# a_41684_232275# VSS VSS nfet_06v0 ad=13p pd=50.52u as=13p ps=50.52u w=50u l=0.7u
X169 a_41684_232275# a_41684_232275# VSS VSS nfet_06v0 ad=13p pd=50.52u as=13p ps=50.52u w=50u l=0.7u
X170 VDD FS_N_GATE FS_N_WELL FS_N_WELL pfet_03v3 ad=6.16p pd=28.88u as=6.16p ps=28.88u w=14u l=0.28u
X171 a_41684_220611# a_41684_220611# a_41684_232275# VSS nfet_06v0 ad=13p pd=50.52u as=13p ps=50.52u w=50u l=0.7u
X172 a_41684_220611# ESD_RAIL ESD_RAIL VSS nfet_06v0 ad=13p pd=50.52u as=13p ps=50.52u w=50u l=0.7u
X173 FS_P_OUT FS_P_GATE FS_P_WELL FS_P_WELL pfet_03v3 ad=6.16p pd=28.88u as=6.16p ps=28.88u w=14u l=0.28u
X174 a_41684_232275# a_41684_232275# VSS VSS nfet_06v0 ad=13p pd=50.52u as=13p ps=50.52u w=50u l=0.7u
X175 a_41684_232275# a_41684_220611# a_41684_220611# VSS nfet_06v0 ad=13p pd=50.52u as=13p ps=50.52u w=50u l=0.7u
X176 HS_N_7 HS_N PAD_N VSS nfet_06v0 ad=8.8p pd=40.88u as=8.8p ps=40.88u w=20u l=0.7u
X177 ESD_RAIL ESD_RAIL a_41684_220611# VSS nfet_06v0 ad=13p pd=50.52u as=13p ps=50.52u w=50u l=0.7u
X178 a_42245_162628# a_44789_189064# ESD_RAIL ESD_RAIL pfet_06v0 ad=1.3p pd=5.52u as=1.3p ps=5.52u w=5u l=0.7u
X179 FS_P_BLEED_6 FS_P_GATE VSS ppolyf_u_1k r_width=1u r_length=12.5u
X180 a_41684_232275# a_41684_232275# VSS VSS nfet_06v0 ad=13p pd=50.52u as=13p ps=50.52u w=50u l=0.7u
X181 a_41684_220611# ESD_RAIL ESD_RAIL VSS nfet_06v0 ad=13p pd=50.52u as=13p ps=50.52u w=50u l=0.7u
X182 a_41684_220611# a_41684_220611# a_41684_232275# VSS nfet_06v0 ad=13p pd=50.52u as=13p ps=50.52u w=50u l=0.7u
X183 FS_P_OUT FS_P_GATE FS_P_WELL FS_P_WELL pfet_03v3 ad=6.16p pd=28.88u as=6.16p ps=28.88u w=14u l=0.28u
X184 VDD PULLUP_P_GATE PULLUP_P_WELL PULLUP_P_WELL pfet_03v3 ad=8.8p pd=40.88u as=8.8p ps=40.88u w=20u l=0.28u
X185 a_41684_220611# ESD_RAIL ESD_RAIL VSS nfet_06v0 ad=13p pd=50.52u as=13p ps=50.52u w=50u l=0.7u
X186 a_41684_232275# a_41684_220611# a_41684_220611# VSS nfet_06v0 ad=13p pd=50.52u as=13p ps=50.52u w=50u l=0.7u
X187 ESD_RAIL a_44789_189064# a_42245_162628# ESD_RAIL pfet_06v0 ad=1.3p pd=5.52u as=1.3p ps=5.52u w=5u l=0.7u
X188 TERM_P_R DIFF_ENABLE TERM_N_R VSS nfet_03v3 ad=8.8p pd=40.88u as=8.8p ps=40.88u w=20u l=0.28u
X189 ESD_RAIL ESD_RAIL a_41684_220611# VSS nfet_06v0 ad=13p pd=50.52u as=13p ps=50.52u w=50u l=0.7u
X190 a_41684_220611# ESD_RAIL ESD_RAIL VSS nfet_06v0 ad=13p pd=50.52u as=13p ps=50.52u w=50u l=0.7u
X191 VSS a_42245_162628# ESD_RAIL VSS nfet_06v0 ad=13p pd=50.52u as=13p ps=50.52u w=50u l=0.7u
X192 ESD_RAIL ESD_RAIL a_41684_220611# VSS nfet_06v0 ad=13p pd=50.52u as=13p ps=50.52u w=50u l=0.7u
X193 VDD FS_N_GATE FS_N_WELL FS_N_WELL pfet_03v3 ad=6.16p pd=28.88u as=6.16p ps=28.88u w=14u l=0.28u
X194 a_41684_220611# a_41684_220611# a_41684_232275# VSS nfet_06v0 ad=13p pd=50.52u as=13p ps=50.52u w=50u l=0.7u
X195 ESD_RAIL ESD_RAIL a_41684_220611# VSS nfet_06v0 ad=13p pd=50.52u as=13p ps=50.52u w=50u l=0.7u
X196 HS_N_2 HS_N PAD_N VSS nfet_06v0 ad=8.8p pd=40.88u as=8.8p ps=40.88u w=20u l=0.7u
X197 TERM_OR_N_B TERM_ENABLE VSS VSS nfet_03v3 ad=0.88p pd=4.88u as=0.88p ps=4.88u w=2u l=0.28u
X198 a_41684_220611# a_41684_220611# a_41684_232275# VSS nfet_06v0 ad=13p pd=50.52u as=13p ps=50.52u w=50u l=0.7u
X199 a_41684_232275# a_41684_220611# a_41684_220611# VSS nfet_06v0 ad=13p pd=50.52u as=13p ps=50.52u w=50u l=0.7u
X200 a_41684_220611# a_41684_220611# a_41684_232275# VSS nfet_06v0 ad=13p pd=50.52u as=13p ps=50.52u w=50u l=0.7u
X201 a_41684_220611# ESD_RAIL ESD_RAIL VSS nfet_06v0 ad=13p pd=50.52u as=13p ps=50.52u w=50u l=0.7u
X202 a_41684_220611# a_41684_220611# a_41684_232275# VSS nfet_06v0 ad=13p pd=50.52u as=13p ps=50.52u w=50u l=0.7u
X203 ESD_RAIL ESD_RAIL a_41684_220611# VSS nfet_06v0 ad=13p pd=50.52u as=13p ps=50.52u w=50u l=0.7u
X204 VSS a_42245_162628# ESD_RAIL VSS nfet_06v0 ad=13p pd=50.52u as=13p ps=50.52u w=50u l=0.7u
X205 HS_N_6 HS_PBIAS VDD VDD pfet_03v3 ad=8.8p pd=40.88u as=8.8p ps=40.88u w=20u l=1u
X206 a_41684_232275# a_41684_220611# a_41684_220611# VSS nfet_06v0 ad=13p pd=50.52u as=13p ps=50.52u w=50u l=0.7u
X207 ESD_RAIL ESD_RAIL a_41684_220611# VSS nfet_06v0 ad=13p pd=50.52u as=13p ps=50.52u w=50u l=0.7u
X208 VSS a_42245_162628# ESD_RAIL VSS nfet_06v0 ad=13p pd=50.52u as=13p ps=50.52u w=50u l=0.7u
X209 PULLUP_N_OUT PULLUP_N_GATE PULLUP_N_WELL PULLUP_N_WELL pfet_03v3 ad=8.8p pd=40.88u as=8.8p ps=40.88u w=20u l=0.28u
X210 a_41684_232275# a_41684_220611# a_41684_220611# VSS nfet_06v0 ad=13p pd=50.52u as=13p ps=50.52u w=50u l=0.7u
X211 a_41684_220611# a_41684_220611# a_41684_232275# VSS nfet_06v0 ad=13p pd=50.52u as=13p ps=50.52u w=50u l=0.7u
X212 a_41684_220611# ESD_RAIL ESD_RAIL VSS nfet_06v0 ad=13p pd=50.52u as=13p ps=50.52u w=50u l=0.7u
X213 ESD_RAIL ESD_RAIL a_41684_220611# VSS nfet_06v0 ad=13p pd=50.52u as=13p ps=50.52u w=50u l=0.7u
X214 a_42245_162628# a_44789_189064# VSS VSS nfet_06v0 ad=1.3p pd=5.52u as=1.3p ps=5.52u w=5u l=0.7u
X215 ESD_RAIL a_44789_189064# a_42245_162628# ESD_RAIL pfet_06v0 ad=1.3p pd=5.52u as=1.3p ps=5.52u w=5u l=0.7u
X216 a_41684_232275# a_41684_220611# a_41684_220611# VSS nfet_06v0 ad=13p pd=50.52u as=13p ps=50.52u w=50u l=0.7u
X217 ESD_RAIL ESD_RAIL a_41684_220611# VSS nfet_06v0 ad=13p pd=50.52u as=13p ps=50.52u w=50u l=0.7u
X218 a_41684_232275# a_41684_220611# a_41684_220611# VSS nfet_06v0 ad=13p pd=50.52u as=13p ps=50.52u w=50u l=0.7u
X219 a_42245_162628# a_44789_189064# ESD_RAIL ESD_RAIL pfet_06v0 ad=1.3p pd=5.52u as=1.3p ps=5.52u w=5u l=0.7u
X220 a_41684_220611# a_41684_220611# a_41684_232275# VSS nfet_06v0 ad=13p pd=50.52u as=13p ps=50.52u w=50u l=0.7u
X221 ESD_RAIL ESD_RAIL a_41684_220611# VSS nfet_06v0 ad=13p pd=50.52u as=13p ps=50.52u w=50u l=0.7u
X222 a_41684_232275# a_41684_232275# VSS VSS nfet_06v0 ad=13p pd=50.52u as=13p ps=50.52u w=50u l=0.7u
X223 HS_N_8 HS_PBIAS VDD VDD pfet_03v3 ad=8.8p pd=40.88u as=8.8p ps=40.88u w=20u l=1u
X224 a_41684_220611# ESD_RAIL ESD_RAIL VSS nfet_06v0 ad=13p pd=50.52u as=13p ps=50.52u w=50u l=0.7u
X225 ESD_RAIL a_41005_203545# a_43813_189064# ESD_RAIL pfet_06v0 ad=1.3p pd=5.52u as=1.3p ps=5.52u w=5u l=0.7u
X226 FS_P_BLEED_0 FS_P_BLEED_1 VSS ppolyf_u_1k r_width=1u r_length=12.5u
X227 PULLUP_N_BLEED_3 PULLUP_N_BLEED_4 VSS ppolyf_u_1k r_width=1u r_length=12.5u
X228 a_41684_232275# a_41684_220611# a_41684_220611# VSS nfet_06v0 ad=13p pd=50.52u as=13p ps=50.52u w=50u l=0.7u
X229 a_41684_220611# ESD_RAIL ESD_RAIL VSS nfet_06v0 ad=13p pd=50.52u as=13p ps=50.52u w=50u l=0.7u
X230 FS_N_OUT PAD_N VSS ppolyf_s r_width=2u r_length=3.5u
X231 FS_P_OUT FS_P_GATE FS_P_WELL FS_P_WELL pfet_03v3 ad=6.16p pd=28.88u as=6.16p ps=28.88u w=14u l=0.28u
X232 a_41684_220611# a_41684_220611# a_41684_232275# VSS nfet_06v0 ad=13p pd=50.52u as=13p ps=50.52u w=50u l=0.7u
X233 a_41684_232275# a_41684_220611# a_41684_220611# VSS nfet_06v0 ad=13p pd=50.52u as=13p ps=50.52u w=50u l=0.7u
X234 ESD_RAIL ESD_RAIL a_41684_220611# VSS nfet_06v0 ad=13p pd=50.52u as=13p ps=50.52u w=50u l=0.7u
X235 ESD_RAIL ESD_RAIL a_41684_220611# VSS nfet_06v0 ad=13p pd=50.52u as=13p ps=50.52u w=50u l=0.7u
X236 a_41005_203825# a_53878_204105# ESD_RAIL ppolyf_u r_width=0.8u r_length=63.855u
X237 a_41684_220611# a_41684_220611# a_41684_232275# VSS nfet_06v0 ad=13p pd=50.52u as=13p ps=50.52u w=50u l=0.7u
X238 a_41684_232275# a_41684_220611# a_41684_220611# VSS nfet_06v0 ad=13p pd=50.52u as=13p ps=50.52u w=50u l=0.7u
X239 a_41684_220611# ESD_RAIL ESD_RAIL VSS nfet_06v0 ad=13p pd=50.52u as=13p ps=50.52u w=50u l=0.7u
X240 TERM_P_R DIFF_ENABLE TERM_N_R VSS nfet_03v3 ad=8.8p pd=40.88u as=8.8p ps=40.88u w=20u l=0.28u
X241 a_41684_220611# a_41684_220611# a_41684_232275# VSS nfet_06v0 ad=13p pd=50.52u as=13p ps=50.52u w=50u l=0.7u
X242 TERM_OR_P_S TERM_ENABLE VDD VDD pfet_03v3 ad=1.76p pd=8.88u as=1.76p ps=8.88u w=4u l=0.28u
X243 FS_P_BLEED_2 FS_P_BLEED_3 VSS ppolyf_u_1k r_width=1u r_length=12.5u
X244 a_41684_232275# a_41684_232275# VSS VSS nfet_06v0 ad=13p pd=50.52u as=13p ps=50.52u w=50u l=0.7u
X245 a_41684_232275# a_41684_220611# a_41684_220611# VSS nfet_06v0 ad=13p pd=50.52u as=13p ps=50.52u w=50u l=0.7u
X246 a_41684_220611# a_41684_220611# a_41684_232275# VSS nfet_06v0 ad=13p pd=50.52u as=13p ps=50.52u w=50u l=0.7u
X247 a_41684_232275# a_41684_220611# a_41684_220611# VSS nfet_06v0 ad=13p pd=50.52u as=13p ps=50.52u w=50u l=0.7u
X248 FS_P_OUT FS_P_GATE FS_P_WELL FS_P_WELL pfet_03v3 ad=6.16p pd=28.88u as=6.16p ps=28.88u w=14u l=0.28u
X249 VDD PULLUP_P_GATE PULLUP_P_WELL PULLUP_P_WELL pfet_03v3 ad=8.8p pd=40.88u as=8.8p ps=40.88u w=20u l=0.28u
X250 TERM_GATE_N TERM_OR_N_B VDD VDD pfet_03v3 ad=3.52p pd=16.88u as=3.52p ps=16.88u w=8u l=0.28u
X251 VSS a_41684_232275# a_41684_232275# VSS nfet_06v0 ad=13p pd=50.52u as=13p ps=50.52u w=50u l=0.7u
X252 a_42245_162628# a_44789_189064# ESD_RAIL ESD_RAIL pfet_06v0 ad=1.3p pd=5.52u as=1.3p ps=5.52u w=5u l=0.7u
X253 a_41684_220611# a_41684_220611# a_41684_232275# VSS nfet_06v0 ad=13p pd=50.52u as=13p ps=50.52u w=50u l=0.7u
X254 ESD_RAIL ESD_RAIL a_41684_220611# VSS nfet_06v0 ad=13p pd=50.52u as=13p ps=50.52u w=50u l=0.7u
X255 VDD FS_N_GATE FS_N_WELL FS_N_WELL pfet_03v3 ad=6.16p pd=28.88u as=6.16p ps=28.88u w=14u l=0.28u
X256 a_41684_232275# a_41684_232275# VSS VSS nfet_06v0 ad=13p pd=50.52u as=13p ps=50.52u w=50u l=0.7u
X257 a_41684_220611# a_41684_220611# a_41684_232275# VSS nfet_06v0 ad=13p pd=50.52u as=13p ps=50.52u w=50u l=0.7u
X258 a_41684_232275# a_41684_220611# a_41684_220611# VSS nfet_06v0 ad=13p pd=50.52u as=13p ps=50.52u w=50u l=0.7u
X259 TERM_N_R TERM_GATE_N TERM_VCM VSS nfet_03v3 ad=8.8p pd=40.88u as=8.8p ps=40.88u w=20u l=0.28u
X260 a_41684_220611# ESD_RAIL ESD_RAIL VSS nfet_06v0 ad=13p pd=50.52u as=13p ps=50.52u w=50u l=0.7u
X261 VSS a_41684_232275# a_41684_232275# VSS nfet_06v0 ad=13p pd=50.52u as=13p ps=50.52u w=50u l=0.7u
X262 HS_N_13 HS_N PAD_N VSS nfet_06v0 ad=8.8p pd=40.88u as=8.8p ps=40.88u w=20u l=0.7u
X263 a_41684_232275# a_41684_220611# a_41684_220611# VSS nfet_06v0 ad=13p pd=50.52u as=13p ps=50.52u w=50u l=0.7u
X264 a_41684_220611# a_41684_220611# a_41684_232275# VSS nfet_06v0 ad=13p pd=50.52u as=13p ps=50.52u w=50u l=0.7u
X265 ESD_RAIL ESD_RAIL a_41684_220611# VSS nfet_06v0 ad=13p pd=50.52u as=13p ps=50.52u w=50u l=0.7u
X266 ESD_RAIL a_42245_162628# VSS VSS nfet_06v0 ad=13p pd=50.52u as=13p ps=50.52u w=50u l=0.7u
X267 ESD_RAIL a_42245_162628# VSS VSS nfet_06v0 ad=13p pd=50.52u as=13p ps=50.52u w=50u l=0.7u
X268 ESD_RAIL a_42245_162628# VSS VSS nfet_06v0 ad=13p pd=50.52u as=13p ps=50.52u w=50u l=0.7u
X269 FS_P_OUT FS_P_GATE FS_P_WELL FS_P_WELL pfet_03v3 ad=6.16p pd=28.88u as=6.16p ps=28.88u w=14u l=0.28u
X270 VSS a_41684_232275# a_41684_232275# VSS nfet_06v0 ad=13p pd=50.52u as=13p ps=50.52u w=50u l=0.7u
X271 HS_N_2 HS_PBIAS VDD VDD pfet_03v3 ad=8.8p pd=40.88u as=8.8p ps=40.88u w=20u l=1u
X272 a_41684_220611# a_41684_220611# a_41684_232275# VSS nfet_06v0 ad=13p pd=50.52u as=13p ps=50.52u w=50u l=0.7u
X273 a_41684_232275# a_41684_220611# a_41684_220611# VSS nfet_06v0 ad=13p pd=50.52u as=13p ps=50.52u w=50u l=0.7u
X274 a_41684_220611# a_41684_220611# a_41684_232275# VSS nfet_06v0 ad=13p pd=50.52u as=13p ps=50.52u w=50u l=0.7u
X275 a_41684_220611# ESD_RAIL ESD_RAIL VSS nfet_06v0 ad=13p pd=50.52u as=13p ps=50.52u w=50u l=0.7u
X276 a_41684_232275# a_41684_232275# VSS VSS nfet_06v0 ad=13p pd=50.52u as=13p ps=50.52u w=50u l=0.7u
X277 VCM_LOW_OK TERM_VCM VDD VDD pfet_03v3 ad=0.88p pd=4.88u as=0.88p ps=4.88u w=2u l=0.28u
X278 a_41684_232275# a_41684_220611# a_41684_220611# VSS nfet_06v0 ad=13p pd=50.52u as=13p ps=50.52u w=50u l=0.7u
X279 PULLUP_N_BLEED_1 PULLUP_N_BLEED_2 VSS ppolyf_u_1k r_width=1u r_length=12.5u
X280 a_41684_232275# a_41684_220611# a_41684_220611# VSS nfet_06v0 ad=13p pd=50.52u as=13p ps=50.52u w=50u l=0.7u
X281 ESD_RAIL a_42245_162628# VSS VSS nfet_06v0 ad=13p pd=50.52u as=13p ps=50.52u w=50u l=0.7u
X282 VSS a_41684_232275# a_41684_232275# VSS nfet_06v0 ad=13p pd=50.52u as=13p ps=50.52u w=50u l=0.7u
X283 a_41684_220611# a_41684_220611# a_41684_232275# VSS nfet_06v0 ad=13p pd=50.52u as=13p ps=50.52u w=50u l=0.7u
X284 a_41684_220611# a_41684_220611# a_41684_232275# VSS nfet_06v0 ad=13p pd=50.52u as=13p ps=50.52u w=50u l=0.7u
X285 a_41684_232275# a_41684_232275# VSS VSS nfet_06v0 ad=13p pd=50.52u as=13p ps=50.52u w=50u l=0.7u
X286 FS_N_BLEED_6 FS_N_GATE VSS ppolyf_u_1k r_width=1u r_length=12.5u
X287 a_41684_232275# a_41684_220611# a_41684_220611# VSS nfet_06v0 ad=13p pd=50.52u as=13p ps=50.52u w=50u l=0.7u
X288 a_41684_220611# ESD_RAIL ESD_RAIL VSS nfet_06v0 ad=13p pd=50.52u as=13p ps=50.52u w=50u l=0.7u
X289 VSS a_41684_232275# a_41684_232275# VSS nfet_06v0 ad=13p pd=50.52u as=13p ps=50.52u w=50u l=0.7u
X290 a_41684_232275# a_41684_220611# a_41684_220611# VSS nfet_06v0 ad=13p pd=50.52u as=13p ps=50.52u w=50u l=0.7u
X291 HS_P_11 HS_PBIAS VDD VDD pfet_03v3 ad=8.8p pd=40.88u as=8.8p ps=40.88u w=20u l=1u
D5 PAD_N ESD_RAIL diode_pd2nw_06v0 pj=51.8u area=22.5p
X292 a_41684_232275# a_41684_232275# VSS VSS nfet_06v0 ad=13p pd=50.52u as=13p ps=50.52u w=50u l=0.7u
X293 a_41684_220611# a_41684_220611# a_41684_232275# VSS nfet_06v0 ad=13p pd=50.52u as=13p ps=50.52u w=50u l=0.7u
X294 ESD_RAIL ESD_RAIL a_41684_220611# VSS nfet_06v0 ad=13p pd=50.52u as=13p ps=50.52u w=50u l=0.7u
X295 a_41684_232275# a_41684_232275# VSS VSS nfet_06v0 ad=13p pd=50.52u as=13p ps=50.52u w=50u l=0.7u
X296 VSS a_41684_232275# a_41684_232275# VSS nfet_06v0 ad=13p pd=50.52u as=13p ps=50.52u w=50u l=0.7u
X297 a_41684_220611# ESD_RAIL ESD_RAIL VSS nfet_06v0 ad=13p pd=50.52u as=13p ps=50.52u w=50u l=0.7u
X298 a_41684_220611# a_41684_220611# a_41684_232275# VSS nfet_06v0 ad=13p pd=50.52u as=13p ps=50.52u w=50u l=0.7u
X299 ESD_RAIL ESD_RAIL a_41684_220611# VSS nfet_06v0 ad=13p pd=50.52u as=13p ps=50.52u w=50u l=0.7u
X300 a_41005_204945# a_53878_205225# ESD_RAIL ppolyf_u r_width=0.8u r_length=63.855u
X301 a_41684_232275# a_41684_232275# VSS VSS nfet_06v0 ad=13p pd=50.52u as=13p ps=50.52u w=50u l=0.7u
X302 a_41684_232275# a_41684_220611# a_41684_220611# VSS nfet_06v0 ad=13p pd=50.52u as=13p ps=50.52u w=50u l=0.7u
X303 a_41684_232275# a_41684_220611# a_41684_220611# VSS nfet_06v0 ad=13p pd=50.52u as=13p ps=50.52u w=50u l=0.7u
X304 VSS a_41684_232275# a_41684_232275# VSS nfet_06v0 ad=13p pd=50.52u as=13p ps=50.52u w=50u l=0.7u
X305 a_41684_220611# a_41684_220611# a_41684_232275# VSS nfet_06v0 ad=13p pd=50.52u as=13p ps=50.52u w=50u l=0.7u
X306 a_41684_232275# a_41684_220611# a_41684_220611# VSS nfet_06v0 ad=13p pd=50.52u as=13p ps=50.52u w=50u l=0.7u
X307 a_41684_232275# a_41684_232275# VSS VSS nfet_06v0 ad=13p pd=50.52u as=13p ps=50.52u w=50u l=0.7u
X308 a_41684_232275# a_41684_220611# a_41684_220611# VSS nfet_06v0 ad=13p pd=50.52u as=13p ps=50.52u w=50u l=0.7u
X309 a_41684_220611# a_41684_220611# a_41684_232275# VSS nfet_06v0 ad=13p pd=50.52u as=13p ps=50.52u w=50u l=0.7u
X310 a_42245_162628# a_44789_189064# ESD_RAIL ESD_RAIL pfet_06v0 ad=1.3p pd=5.52u as=1.3p ps=5.52u w=5u l=0.7u
X311 FS_P_OUT FS_P_GATE FS_P_WELL FS_P_WELL pfet_03v3 ad=6.16p pd=28.88u as=6.16p ps=28.88u w=14u l=0.28u
X312 FS_N_OUT FS_N_GATE FS_N_WELL FS_N_WELL pfet_03v3 ad=6.16p pd=28.88u as=6.16p ps=28.88u w=14u l=0.28u
X313 a_41684_232275# a_41684_220611# a_41684_220611# VSS nfet_06v0 ad=13p pd=50.52u as=13p ps=50.52u w=50u l=0.7u
X314 VSS a_41684_232275# a_41684_232275# VSS nfet_06v0 ad=13p pd=50.52u as=13p ps=50.52u w=50u l=0.7u
X315 a_41684_232275# a_41684_232275# VSS VSS nfet_06v0 ad=13p pd=50.52u as=13p ps=50.52u w=50u l=0.7u
X316 PULLUP_P_OUT PAD_P VSS ppolyf_u_1k r_width=1u r_length=1.18u
X317 a_41684_220611# a_41684_220611# a_41684_232275# VSS nfet_06v0 ad=13p pd=50.52u as=13p ps=50.52u w=50u l=0.7u
X318 FS_P_OUT FS_P_GATE FS_P_WELL FS_P_WELL pfet_03v3 ad=6.16p pd=28.88u as=6.16p ps=28.88u w=14u l=0.28u
X319 VSS a_42245_162628# ESD_RAIL VSS nfet_06v0 ad=13p pd=50.52u as=13p ps=50.52u w=50u l=0.7u
X320 FS_N_OUT FS_N_GATE FS_N_WELL FS_N_WELL pfet_03v3 ad=6.16p pd=28.88u as=6.16p ps=28.88u w=14u l=0.28u
X321 VSS a_41684_232275# a_41684_232275# VSS nfet_06v0 ad=13p pd=50.52u as=13p ps=50.52u w=50u l=0.7u
X322 a_41684_220611# ESD_RAIL ESD_RAIL VSS nfet_06v0 ad=13p pd=50.52u as=13p ps=50.52u w=50u l=0.7u
X323 a_41684_232275# a_41684_232275# VSS VSS nfet_06v0 ad=13p pd=50.52u as=13p ps=50.52u w=50u l=0.7u
X324 ESD_RAIL ESD_RAIL a_41684_220611# VSS nfet_06v0 ad=13p pd=50.52u as=13p ps=50.52u w=50u l=0.7u
X325 HS_P_3 HS_PBIAS VDD VDD pfet_03v3 ad=8.8p pd=40.88u as=8.8p ps=40.88u w=20u l=1u
X326 FS_P_OUT FS_P_GATE FS_P_WELL FS_P_WELL pfet_03v3 ad=6.16p pd=28.88u as=6.16p ps=28.88u w=14u l=0.28u
X327 FS_N_BLEED_0 FS_N_BLEED_1 VSS ppolyf_u_1k r_width=1u r_length=12.5u
X328 VSS a_42245_162628# ESD_RAIL VSS nfet_06v0 ad=13p pd=50.52u as=13p ps=50.52u w=50u l=0.7u
X329 VSS a_41684_232275# a_41684_232275# VSS nfet_06v0 ad=13p pd=50.52u as=13p ps=50.52u w=50u l=0.7u
X330 VSS a_42245_162628# ESD_RAIL VSS nfet_06v0 ad=13p pd=50.52u as=22p ps=0.10088m w=50u l=0.7u
X331 TERM_OR_N_NS VCM_LOW_OK VSS VSS nfet_03v3 ad=1.76p pd=8.88u as=1.76p ps=8.88u w=4u l=0.28u
X332 VSS a_41684_232275# a_41684_232275# VSS nfet_06v0 ad=13p pd=50.52u as=13p ps=50.52u w=50u l=0.7u
X333 VSS a_44789_189064# a_42245_162628# VSS nfet_06v0 ad=2.2p pd=10.88u as=1.3p ps=5.52u w=5u l=0.7u
X334 ESD_RAIL a_44789_189064# a_42245_162628# ESD_RAIL pfet_06v0 ad=1.3p pd=5.52u as=1.3p ps=5.52u w=5u l=0.7u
X335 a_42245_162628# a_44789_189064# ESD_RAIL ESD_RAIL pfet_06v0 ad=1.3p pd=5.52u as=1.3p ps=5.52u w=5u l=0.7u
X336 a_41684_232275# a_41684_232275# VSS VSS nfet_06v0 ad=13p pd=50.52u as=13p ps=50.52u w=50u l=0.7u
X337 VSS a_41684_232275# a_41684_232275# VSS nfet_06v0 ad=13p pd=50.52u as=13p ps=50.52u w=50u l=0.7u
X338 VSS a_42245_162628# ESD_RAIL VSS nfet_06v0 ad=13p pd=50.52u as=13p ps=50.52u w=50u l=0.7u
X339 ESD_RAIL a_44789_189064# a_42245_162628# ESD_RAIL pfet_06v0 ad=1.3p pd=5.52u as=1.3p ps=5.52u w=5u l=0.7u
X340 ESD_RAIL ESD_RAIL a_41684_220611# VSS nfet_06v0 ad=13p pd=50.52u as=13p ps=50.52u w=50u l=0.7u
X341 ESD_RAIL a_42245_162628# VSS VSS nfet_06v0 ad=22p pd=0.10088m as=13p ps=50.52u w=50u l=0.7u
X342 FS_P_OUT FS_P_GATE FS_P_WELL FS_P_WELL pfet_03v3 ad=6.16p pd=28.88u as=6.16p ps=28.88u w=14u l=0.28u
X343 a_41684_232275# a_41684_232275# VSS VSS nfet_06v0 ad=13p pd=50.52u as=13p ps=50.52u w=50u l=0.7u
X344 a_41684_232275# a_41684_232275# VSS VSS nfet_06v0 ad=13p pd=50.52u as=13p ps=50.52u w=50u l=0.7u
X345 VSS a_41684_232275# a_41684_232275# VSS nfet_06v0 ad=13p pd=50.52u as=13p ps=50.52u w=50u l=0.7u
X346 FS_P_OUT FS_P_GATE FS_P_WELL FS_P_WELL pfet_03v3 ad=6.16p pd=28.88u as=6.16p ps=28.88u w=14u l=0.28u
X347 a_41684_232275# a_41684_232275# VSS VSS nfet_06v0 ad=13p pd=50.52u as=13p ps=50.52u w=50u l=0.7u
X348 VSS a_41684_232275# a_41684_232275# VSS nfet_06v0 ad=13p pd=50.52u as=13p ps=50.52u w=50u l=0.7u
X349 a_41005_206065# a_53878_206345# ESD_RAIL ppolyf_u r_width=0.8u r_length=63.855u
X350 FS_N_OUT FS_N_GATE FS_N_WELL FS_N_WELL pfet_03v3 ad=6.16p pd=28.88u as=6.16p ps=28.88u w=14u l=0.28u
X351 VDD PULLUP_N_GATE PULLUP_N_WELL PULLUP_N_WELL pfet_03v3 ad=8.8p pd=40.88u as=8.8p ps=40.88u w=20u l=0.28u
X352 a_41684_232275# a_41684_232275# VSS VSS nfet_06v0 ad=13p pd=50.52u as=13p ps=50.52u w=50u l=0.7u
X353 VSS a_41684_232275# a_41684_232275# VSS nfet_06v0 ad=13p pd=50.52u as=13p ps=50.52u w=50u l=0.7u
X354 a_41684_232275# a_41684_232275# VSS VSS nfet_06v0 ad=13p pd=50.52u as=13p ps=50.52u w=50u l=0.7u
X355 FS_N_OUT FS_N_GATE FS_N_WELL FS_N_WELL pfet_03v3 ad=6.16p pd=28.88u as=6.16p ps=28.88u w=14u l=0.28u
X356 a_42245_162628# a_44789_189064# VSS VSS nfet_06v0 ad=1.3p pd=5.52u as=1.3p ps=5.52u w=5u l=0.7u
X357 ESD_RAIL a_44789_189064# a_42245_162628# ESD_RAIL pfet_06v0 ad=1.3p pd=5.52u as=1.3p ps=5.52u w=5u l=0.7u
X358 a_41684_232275# a_41684_220611# a_41684_220611# VSS nfet_06v0 ad=13p pd=50.52u as=13p ps=50.52u w=50u l=0.7u
X359 a_42245_162628# a_44789_189064# ESD_RAIL ESD_RAIL pfet_06v0 ad=1.3p pd=5.52u as=2.2p ps=10.88u w=5u l=0.7u
X360 HS_P_13 HS_PBIAS VDD VDD pfet_03v3 ad=8.8p pd=40.88u as=8.8p ps=40.88u w=20u l=1u
X361 a_43813_189064# a_41005_203545# VSS VSS nfet_06v0 ad=2.2p pd=10.88u as=2.2p ps=10.88u w=5u l=0.7u
X362 ESD_RAIL ESD_RAIL a_41684_220611# VSS nfet_06v0 ad=13p pd=50.52u as=13p ps=50.52u w=50u l=0.7u
X363 a_41684_220611# ESD_RAIL ESD_RAIL VSS nfet_06v0 ad=13p pd=50.52u as=13p ps=50.52u w=50u l=0.7u
X364 ESD_RAIL a_42245_162628# VSS VSS nfet_06v0 ad=13p pd=50.52u as=13p ps=50.52u w=50u l=0.7u
X365 TERM_P_R DIFF_ENABLE TERM_N_R VSS nfet_03v3 ad=8.8p pd=40.88u as=8.8p ps=40.88u w=20u l=0.28u
X366 a_41684_232275# a_41684_220611# a_41684_220611# VSS nfet_06v0 ad=13p pd=50.52u as=13p ps=50.52u w=50u l=0.7u
X367 PAD_N DIV_N VSS ppolyf_u_1k r_width=1u r_length=2u
X368 a_41684_232275# a_41684_232275# VSS VSS nfet_06v0 ad=13p pd=50.52u as=13p ps=50.52u w=50u l=0.7u
X369 ESD_RAIL ESD_RAIL a_41684_220611# VSS nfet_06v0 ad=13p pd=50.52u as=13p ps=50.52u w=50u l=0.7u
X370 TERM_GATE_N_BLEED_1 TERM_GATE_N_BLEED_2 VSS ppolyf_u_1k r_width=1u r_length=12.5u
X371 ESD_RAIL VSS cap_mim_2f0_m4m5_noshield c_width=31.6u c_length=31.6u
X372 a_41684_220611# ESD_RAIL ESD_RAIL VSS nfet_06v0 ad=13p pd=50.52u as=13p ps=50.52u w=50u l=0.7u
X373 ESD_RAIL a_42245_162628# VSS VSS nfet_06v0 ad=13p pd=50.52u as=13p ps=50.52u w=50u l=0.7u
X374 a_41684_220611# a_41684_220611# a_41684_232275# VSS nfet_06v0 ad=13p pd=50.52u as=13p ps=50.52u w=50u l=0.7u
X375 ESD_RAIL a_42245_162628# VSS VSS nfet_06v0 ad=13p pd=50.52u as=13p ps=50.52u w=50u l=0.7u
X376 a_42245_162628# a_44789_189064# VSS VSS nfet_06v0 ad=1.3p pd=5.52u as=1.3p ps=5.52u w=5u l=0.7u
X377 a_41684_232275# a_41684_232275# VSS VSS nfet_06v0 ad=13p pd=50.52u as=13p ps=50.52u w=50u l=0.7u
X378 ESD_RAIL ESD_RAIL a_41684_220611# VSS nfet_06v0 ad=13p pd=50.52u as=13p ps=50.52u w=50u l=0.7u
X379 VSS a_42245_162628# ESD_RAIL VSS nfet_06v0 ad=13p pd=50.52u as=13p ps=50.52u w=50u l=0.7u
X380 PULLUP_P_BLEED_4 PULLUP_P_BLEED_5 VSS ppolyf_u_1k r_width=1u r_length=12.5u
X381 FS_N_OUT FS_N_GATE FS_N_WELL FS_N_WELL pfet_03v3 ad=6.16p pd=28.88u as=6.16p ps=28.88u w=14u l=0.28u
X382 ESD_RAIL ESD_RAIL a_41684_220611# VSS nfet_06v0 ad=13p pd=50.52u as=13p ps=50.52u w=50u l=0.7u
X383 a_41684_220611# ESD_RAIL ESD_RAIL VSS nfet_06v0 ad=13p pd=50.52u as=13p ps=50.52u w=50u l=0.7u
X384 VSS a_43813_189064# a_44789_189064# VSS nfet_06v0 ad=1.3p pd=5.52u as=1.3p ps=5.52u w=5u l=0.7u
X385 a_42245_162628# a_44789_189064# ESD_RAIL ESD_RAIL pfet_06v0 ad=1.3p pd=5.52u as=1.3p ps=5.52u w=5u l=0.7u
X386 FS_N_OUT FS_N_GATE FS_N_WELL FS_N_WELL pfet_03v3 ad=6.16p pd=28.88u as=6.16p ps=28.88u w=14u l=0.28u
X387 FS_P_OUT FS_P_GATE FS_P_WELL FS_P_WELL pfet_03v3 ad=6.16p pd=28.88u as=6.16p ps=28.88u w=14u l=0.28u
X388 ESD_RAIL ESD_RAIL a_41684_220611# VSS nfet_06v0 ad=13p pd=50.52u as=13p ps=50.52u w=50u l=0.7u
X389 a_41684_220611# a_41684_220611# a_41684_232275# VSS nfet_06v0 ad=13p pd=50.52u as=13p ps=50.52u w=50u l=0.7u
X390 VSS a_41684_232275# a_41684_232275# VSS nfet_06v0 ad=13p pd=50.52u as=13p ps=50.52u w=50u l=0.7u
X391 ESD_RAIL ESD_RAIL a_41684_220611# VSS nfet_06v0 ad=13p pd=50.52u as=13p ps=50.52u w=50u l=0.7u
X392 a_41684_220611# ESD_RAIL ESD_RAIL VSS nfet_06v0 ad=13p pd=50.52u as=13p ps=50.52u w=50u l=0.7u
X393 FS_N_CONTROL_S VDD VSS VSS nfet_03v3 ad=1.76p pd=8.88u as=1.76p ps=8.88u w=4u l=0.28u
X394 FS_N_OUT FS_N_GATE FS_N_WELL FS_N_WELL pfet_03v3 ad=6.16p pd=28.88u as=6.16p ps=28.88u w=14u l=0.28u
X395 a_41684_220611# ESD_RAIL ESD_RAIL VSS nfet_06v0 ad=13p pd=50.52u as=13p ps=50.52u w=50u l=0.7u
X396 a_41684_220611# a_41684_220611# a_41684_232275# VSS nfet_06v0 ad=13p pd=50.52u as=13p ps=50.52u w=50u l=0.7u
X397 ESD_RAIL ESD_RAIL a_41684_220611# VSS nfet_06v0 ad=13p pd=50.52u as=13p ps=50.52u w=50u l=0.7u
D6 PAD_P ESD_RAIL diode_pd2nw_06v0 pj=51.8u area=22.5p
X398 PULLUP_N_BLEED_5 PULLUP_N_BLEED_6 VSS ppolyf_u_1k r_width=1u r_length=12.5u
D7 PAD_N ESD_RAIL diode_pd2nw_06v0 pj=51.8u area=22.5p
X399 VSS a_41684_232275# a_41684_232275# VSS nfet_06v0 ad=13p pd=50.52u as=13p ps=50.52u w=50u l=0.7u
X400 a_41684_220611# ESD_RAIL ESD_RAIL VSS nfet_06v0 ad=13p pd=50.52u as=13p ps=50.52u w=50u l=0.7u
X401 a_41684_220611# ESD_RAIL ESD_RAIL VSS nfet_06v0 ad=13p pd=50.52u as=13p ps=50.52u w=50u l=0.7u
X402 ESD_RAIL ESD_RAIL a_41684_220611# VSS nfet_06v0 ad=13p pd=50.52u as=13p ps=50.52u w=50u l=0.7u
X403 a_41684_232275# a_41684_220611# a_41684_220611# VSS nfet_06v0 ad=13p pd=50.52u as=13p ps=50.52u w=50u l=0.7u
X404 VSS a_43813_189064# a_44789_189064# VSS nfet_06v0 ad=1.3p pd=5.52u as=1.3p ps=5.52u w=5u l=0.7u
X405 a_41684_220611# ESD_RAIL ESD_RAIL VSS nfet_06v0 ad=13p pd=50.52u as=13p ps=50.52u w=50u l=0.7u
X406 ESD_RAIL ESD_RAIL a_41684_220611# VSS nfet_06v0 ad=13p pd=50.52u as=13p ps=50.52u w=50u l=0.7u
X407 TERM_OR_P_B VCM_LOW_OK TERM_OR_P_S VDD pfet_03v3 ad=1.76p pd=8.88u as=1.76p ps=8.88u w=4u l=0.28u
X408 VCM_LOW_OK TERM_VCM VSS VSS nfet_03v3 ad=3.52p pd=16.88u as=3.52p ps=16.88u w=8u l=0.28u
X409 VSS ESD_RAIL VSS ppolyf_u_1k_6p0 r_width=1u r_length=9.98874m
X410 PULLUP_P_GATE PULLUP_P PULLUP_P_CONTROL_S VSS nfet_06v0 ad=0.88p pd=4.88u as=0.88p ps=4.88u w=2u l=0.7u
X411 a_41684_232275# a_41684_220611# a_41684_220611# VSS nfet_06v0 ad=13p pd=50.52u as=13p ps=50.52u w=50u l=0.7u
X412 a_41684_220611# ESD_RAIL ESD_RAIL VSS nfet_06v0 ad=13p pd=50.52u as=13p ps=50.52u w=50u l=0.7u
X413 a_41684_232275# a_41684_220611# a_41684_220611# VSS nfet_06v0 ad=13p pd=50.52u as=13p ps=50.52u w=50u l=0.7u
X414 a_41684_232275# a_41684_232275# VSS VSS nfet_06v0 ad=13p pd=50.52u as=13p ps=50.52u w=50u l=0.7u
X415 ESD_RAIL ESD_RAIL a_41684_220611# VSS nfet_06v0 ad=13p pd=50.52u as=13p ps=50.52u w=50u l=0.7u
X416 a_41684_220611# ESD_RAIL ESD_RAIL VSS nfet_06v0 ad=13p pd=50.52u as=13p ps=50.52u w=50u l=0.7u
X417 ESD_RAIL ESD_RAIL a_41684_220611# VSS nfet_06v0 ad=13p pd=50.52u as=13p ps=50.52u w=50u l=0.7u
X418 a_41684_220611# ESD_RAIL ESD_RAIL VSS nfet_06v0 ad=13p pd=50.52u as=13p ps=50.52u w=50u l=0.7u
X419 ESD_RAIL ESD_RAIL a_41684_220611# VSS nfet_06v0 ad=13p pd=50.52u as=13p ps=50.52u w=50u l=0.7u
X420 TERM_GATE_P_BLEED_2 VSS VSS ppolyf_u_1k r_width=1u r_length=12.5u
X421 FS_N_OUT FS_N_GATE FS_N_WELL FS_N_WELL pfet_03v3 ad=6.16p pd=28.88u as=6.16p ps=28.88u w=14u l=0.28u
X422 a_41684_220611# ESD_RAIL ESD_RAIL VSS nfet_06v0 ad=13p pd=50.52u as=13p ps=50.52u w=50u l=0.7u
X423 ESD_RAIL ESD_RAIL a_41684_220611# VSS nfet_06v0 ad=13p pd=50.52u as=13p ps=50.52u w=50u l=0.7u
X424 ESD_RAIL ESD_RAIL a_41684_220611# VSS nfet_06v0 ad=13p pd=50.52u as=13p ps=50.52u w=50u l=0.7u
X425 VSS a_42245_162628# ESD_RAIL VSS nfet_06v0 ad=13p pd=50.52u as=13p ps=50.52u w=50u l=0.7u
X426 a_41684_220611# ESD_RAIL ESD_RAIL VSS nfet_06v0 ad=13p pd=50.52u as=13p ps=50.52u w=50u l=0.7u
X427 ESD_RAIL a_42245_162628# VSS VSS nfet_06v0 ad=13p pd=50.52u as=13p ps=50.52u w=50u l=0.7u
X428 a_41684_220611# a_41684_220611# a_41684_232275# VSS nfet_06v0 ad=13p pd=50.52u as=13p ps=50.52u w=50u l=0.7u
X429 HS_N_11 HS_PBIAS VDD VDD pfet_03v3 ad=8.8p pd=40.88u as=8.8p ps=40.88u w=20u l=1u
X430 a_41684_220611# a_41684_220611# a_41684_232275# VSS nfet_06v0 ad=13p pd=50.52u as=13p ps=50.52u w=50u l=0.7u
X431 a_41684_220611# ESD_RAIL ESD_RAIL VSS nfet_06v0 ad=13p pd=50.52u as=13p ps=50.52u w=50u l=0.7u
X432 ESD_RAIL ESD_RAIL a_41684_220611# VSS nfet_06v0 ad=13p pd=50.52u as=13p ps=50.52u w=50u l=0.7u
X433 VSS a_41684_232275# a_41684_232275# VSS nfet_06v0 ad=13p pd=50.52u as=13p ps=50.52u w=50u l=0.7u
X434 ESD_RAIL ESD_RAIL a_41684_220611# VSS nfet_06v0 ad=13p pd=50.52u as=13p ps=50.52u w=50u l=0.7u
X435 a_41684_220611# ESD_RAIL ESD_RAIL VSS nfet_06v0 ad=13p pd=50.52u as=13p ps=50.52u w=50u l=0.7u
X436 a_41684_220611# a_41684_220611# a_41684_232275# VSS nfet_06v0 ad=13p pd=50.52u as=13p ps=50.52u w=50u l=0.7u
X437 a_41684_220611# a_41684_220611# a_41684_232275# VSS nfet_06v0 ad=13p pd=50.52u as=13p ps=50.52u w=50u l=0.7u
X438 ESD_RAIL ESD_RAIL a_41684_220611# VSS nfet_06v0 ad=13p pd=50.52u as=13p ps=50.52u w=50u l=0.7u
X439 a_41684_220611# ESD_RAIL ESD_RAIL VSS nfet_06v0 ad=13p pd=50.52u as=13p ps=50.52u w=50u l=0.7u
X440 HS_P_10 HS_P PAD_P VSS nfet_06v0 ad=8.8p pd=40.88u as=8.8p ps=40.88u w=20u l=0.7u
X441 a_41684_220611# ESD_RAIL ESD_RAIL VSS nfet_06v0 ad=13p pd=50.52u as=13p ps=50.52u w=50u l=0.7u
X442 FS_N_OUT FS_N_GATE FS_N_WELL FS_N_WELL pfet_03v3 ad=6.16p pd=28.88u as=6.16p ps=28.88u w=14u l=0.28u
X443 a_41684_232275# a_41684_220611# a_41684_220611# VSS nfet_06v0 ad=13p pd=50.52u as=13p ps=50.52u w=50u l=0.7u
X444 ESD_RAIL ESD_RAIL a_41684_220611# VSS nfet_06v0 ad=13p pd=50.52u as=13p ps=50.52u w=50u l=0.7u
X445 ESD_RAIL ESD_RAIL a_41684_220611# VSS nfet_06v0 ad=13p pd=50.52u as=13p ps=50.52u w=50u l=0.7u
X446 a_41684_232275# a_41684_220611# a_41684_220611# VSS nfet_06v0 ad=13p pd=50.52u as=13p ps=50.52u w=50u l=0.7u
X447 TERM_P_R TERM_GATE_P TERM_VCM VSS nfet_03v3 ad=8.8p pd=40.88u as=8.8p ps=40.88u w=20u l=0.28u
X448 PAD_N PULLDOWN_N_R VSS ppolyf_u_1k r_width=1u r_length=14.2u
X449 a_41684_220611# a_41684_220611# a_41684_232275# VSS nfet_06v0 ad=13p pd=50.52u as=13p ps=50.52u w=50u l=0.7u
X450 a_41684_220611# ESD_RAIL ESD_RAIL VSS nfet_06v0 ad=13p pd=50.52u as=13p ps=50.52u w=50u l=0.7u
X451 PAD_P BYPASS_ENABLE RX_P VSS nfet_06v0 ad=8.8p pd=40.88u as=8.8p ps=40.88u w=20u l=0.7u
X452 a_41684_220611# ESD_RAIL ESD_RAIL VSS nfet_06v0 ad=13p pd=50.52u as=13p ps=50.52u w=50u l=0.7u
X453 FS_N_OUT FS_N_GATE FS_N_WELL FS_N_WELL pfet_03v3 ad=6.16p pd=28.88u as=6.16p ps=28.88u w=14u l=0.28u
X454 a_41684_232275# a_41684_220611# a_41684_220611# VSS nfet_06v0 ad=13p pd=50.52u as=13p ps=50.52u w=50u l=0.7u
X455 ESD_RAIL ESD_RAIL a_41684_220611# VSS nfet_06v0 ad=13p pd=50.52u as=13p ps=50.52u w=50u l=0.7u
X456 HS_P_5 HS_P PAD_P VSS nfet_06v0 ad=8.8p pd=40.88u as=8.8p ps=40.88u w=20u l=0.7u
X457 a_41684_232275# a_41684_220611# a_41684_220611# VSS nfet_06v0 ad=13p pd=50.52u as=13p ps=50.52u w=50u l=0.7u
X458 a_41684_220611# a_41684_220611# a_41684_232275# VSS nfet_06v0 ad=13p pd=50.52u as=13p ps=50.52u w=50u l=0.7u
X459 a_41684_232275# a_41684_220611# a_41684_220611# VSS nfet_06v0 ad=13p pd=50.52u as=13p ps=50.52u w=50u l=0.7u
X460 ESD_RAIL ESD_RAIL a_41684_220611# VSS nfet_06v0 ad=13p pd=50.52u as=13p ps=50.52u w=50u l=0.7u
X461 DIV_P DIV_ENABLE RX_P VSS nfet_06v0 ad=8.8p pd=40.88u as=8.8p ps=40.88u w=20u l=0.7u
X462 a_41684_232275# a_41684_220611# a_41684_220611# VSS nfet_06v0 ad=13p pd=50.52u as=13p ps=50.52u w=50u l=0.7u
X463 a_41684_220611# ESD_RAIL ESD_RAIL VSS nfet_06v0 ad=13p pd=50.52u as=13p ps=50.52u w=50u l=0.7u
X464 a_41684_232275# a_41684_220611# a_41684_220611# VSS nfet_06v0 ad=13p pd=50.52u as=13p ps=50.52u w=50u l=0.7u
X465 a_41684_220611# a_41684_220611# a_41684_232275# VSS nfet_06v0 ad=13p pd=50.52u as=13p ps=50.52u w=50u l=0.7u
X466 ESD_RAIL a_42245_162628# VSS VSS nfet_06v0 ad=13p pd=50.52u as=13p ps=50.52u w=50u l=0.7u
X467 a_41684_220611# ESD_RAIL ESD_RAIL VSS nfet_06v0 ad=13p pd=50.52u as=13p ps=50.52u w=50u l=0.7u
X468 HS_P_6 HS_P PAD_P VSS nfet_06v0 ad=8.8p pd=40.88u as=8.8p ps=40.88u w=20u l=0.7u
X469 FS_N_OUT FS_N_GATE FS_N_WELL FS_N_WELL pfet_03v3 ad=6.16p pd=28.88u as=6.16p ps=28.88u w=14u l=0.28u
X470 VSS a_41684_232275# a_41684_232275# VSS nfet_06v0 ad=13p pd=50.52u as=13p ps=50.52u w=50u l=0.7u
X471 ESD_RAIL ESD_RAIL a_41684_220611# VSS nfet_06v0 ad=13p pd=50.52u as=13p ps=50.52u w=50u l=0.7u
X472 a_41684_220611# ESD_RAIL ESD_RAIL VSS nfet_06v0 ad=13p pd=50.52u as=13p ps=50.52u w=50u l=0.7u
X473 ESD_RAIL ESD_RAIL a_41684_220611# VSS nfet_06v0 ad=13p pd=50.52u as=13p ps=50.52u w=50u l=0.7u
X474 a_41684_220611# a_41684_220611# a_41684_232275# VSS nfet_06v0 ad=13p pd=50.52u as=13p ps=50.52u w=50u l=0.7u
X475 a_41684_220611# ESD_RAIL ESD_RAIL VSS nfet_06v0 ad=13p pd=50.52u as=13p ps=50.52u w=50u l=0.7u
X476 a_41684_220611# ESD_RAIL ESD_RAIL VSS nfet_06v0 ad=13p pd=50.52u as=13p ps=50.52u w=50u l=0.7u
D8 PAD_P ESD_RAIL diode_pd2nw_06v0 pj=51.8u area=22.5p
X477 a_41684_232275# a_41684_220611# a_41684_220611# VSS nfet_06v0 ad=13p pd=50.52u as=13p ps=50.52u w=50u l=0.7u
X478 VSS a_41684_232275# a_41684_232275# VSS nfet_06v0 ad=13p pd=50.52u as=13p ps=50.52u w=50u l=0.7u
X479 ESD_RAIL ESD_RAIL a_41684_220611# VSS nfet_06v0 ad=13p pd=50.52u as=13p ps=50.52u w=50u l=0.7u
X480 a_41684_232275# a_41684_232275# VSS VSS nfet_06v0 ad=13p pd=50.52u as=13p ps=50.52u w=50u l=0.7u
X481 VSS a_41684_232275# a_41684_232275# VSS nfet_06v0 ad=13p pd=50.52u as=13p ps=50.52u w=50u l=0.7u
X482 VSS a_42245_162628# ESD_RAIL VSS nfet_06v0 ad=13p pd=50.52u as=13p ps=50.52u w=50u l=0.7u
X483 VSS a_42245_162628# ESD_RAIL VSS nfet_06v0 ad=13p pd=50.52u as=13p ps=50.52u w=50u l=0.7u
X484 VSS a_41684_232275# a_41684_232275# VSS nfet_06v0 ad=13p pd=50.52u as=13p ps=50.52u w=50u l=0.7u
X485 a_41684_220611# a_41684_220611# a_41684_232275# VSS nfet_06v0 ad=13p pd=50.52u as=13p ps=50.52u w=50u l=0.7u
X486 FS_N_OUT FS_N_GATE FS_N_WELL FS_N_WELL pfet_03v3 ad=6.16p pd=28.88u as=6.16p ps=28.88u w=14u l=0.28u
X487 a_41684_232275# a_41684_220611# a_41684_220611# VSS nfet_06v0 ad=13p pd=50.52u as=13p ps=50.52u w=50u l=0.7u
X488 VSS a_41684_232275# a_41684_232275# VSS nfet_06v0 ad=13p pd=50.52u as=13p ps=50.52u w=50u l=0.7u
X489 ESD_RAIL ATB_ESD_RAIL VSS ppolyf_u_1k_6p0 r_width=1u r_length=0.47474m
X490 VSS a_42245_162628# ESD_RAIL VSS nfet_06v0 ad=13p pd=50.52u as=13p ps=50.52u w=50u l=0.7u
X491 a_41684_232275# a_41684_220611# a_41684_220611# VSS nfet_06v0 ad=13p pd=50.52u as=13p ps=50.52u w=50u l=0.7u
X492 VSS a_41684_232275# a_41684_232275# VSS nfet_06v0 ad=13p pd=50.52u as=13p ps=50.52u w=50u l=0.7u
X493 VDD PULLUP_N_GATE PULLUP_N_WELL PULLUP_N_WELL pfet_03v3 ad=8.8p pd=40.88u as=8.8p ps=40.88u w=20u l=0.28u
X494 a_41684_232275# a_41684_232275# VSS VSS nfet_06v0 ad=13p pd=50.52u as=13p ps=50.52u w=50u l=0.7u
X495 a_41684_220611# a_41684_220611# a_41684_232275# VSS nfet_06v0 ad=13p pd=50.52u as=13p ps=50.52u w=50u l=0.7u
X496 a_41684_232275# a_41684_232275# VSS VSS nfet_06v0 ad=13p pd=50.52u as=13p ps=50.52u w=50u l=0.7u
X497 TERM_P_R TERM_GATE_P TERM_VCM VSS nfet_03v3 ad=8.8p pd=40.88u as=8.8p ps=40.88u w=20u l=0.28u
X498 a_41684_232275# a_41684_220611# a_41684_220611# VSS nfet_06v0 ad=13p pd=50.52u as=13p ps=50.52u w=50u l=0.7u
X499 VSS a_41684_232275# a_41684_232275# VSS nfet_06v0 ad=13p pd=50.52u as=13p ps=50.52u w=50u l=0.7u
X500 VSS a_41684_232275# a_41684_232275# VSS nfet_06v0 ad=13p pd=50.52u as=13p ps=50.52u w=50u l=0.7u
X501 a_41684_220611# a_41684_220611# a_41684_232275# VSS nfet_06v0 ad=13p pd=50.52u as=13p ps=50.52u w=50u l=0.7u
X502 a_41684_232275# a_41684_232275# VSS VSS nfet_06v0 ad=13p pd=50.52u as=13p ps=50.52u w=50u l=0.7u
X503 HS_P_3 HS_P PAD_P VSS nfet_06v0 ad=8.8p pd=40.88u as=8.8p ps=40.88u w=20u l=0.7u
X504 a_41684_232275# a_41684_232275# VSS VSS nfet_06v0 ad=13p pd=50.52u as=13p ps=50.52u w=50u l=0.7u
X505 FS_P_WELL FS_P_BLEED_0 VSS ppolyf_u_1k r_width=1u r_length=12.5u
X506 VDD FS_P_GATE FS_P_WELL FS_P_WELL pfet_03v3 ad=6.16p pd=28.88u as=6.16p ps=28.88u w=14u l=0.28u
X507 VSS a_41684_232275# a_41684_232275# VSS nfet_06v0 ad=13p pd=50.52u as=13p ps=50.52u w=50u l=0.7u
X508 a_41684_232275# a_41684_232275# VSS VSS nfet_06v0 ad=13p pd=50.52u as=13p ps=50.52u w=50u l=0.7u
X509 VSS a_41684_232275# a_41684_232275# VSS nfet_06v0 ad=13p pd=50.52u as=13p ps=50.52u w=50u l=0.7u
X510 VSS a_42245_162628# ESD_RAIL VSS nfet_06v0 ad=13p pd=50.52u as=13p ps=50.52u w=50u l=0.7u
X511 a_41684_232275# a_41684_232275# VSS VSS nfet_06v0 ad=13p pd=50.52u as=13p ps=50.52u w=50u l=0.7u
D9 VSS ESD_RAIL diode_nd2ps_06v0 pj=82u area=40p
X512 VSS a_41684_232275# a_41684_232275# VSS nfet_06v0 ad=13p pd=50.52u as=13p ps=50.52u w=50u l=0.7u
X513 a_41684_220611# a_41684_220611# a_41684_232275# VSS nfet_06v0 ad=13p pd=50.52u as=13p ps=50.52u w=50u l=0.7u
X514 a_41684_232275# a_41684_232275# VSS VSS nfet_06v0 ad=13p pd=50.52u as=13p ps=50.52u w=50u l=0.7u
X515 VSS a_41684_232275# a_41684_232275# VSS nfet_06v0 ad=22p pd=0.10088m as=13p ps=50.52u w=50u l=0.7u
X516 FS_P_BLEED_1 FS_P_BLEED_2 VSS ppolyf_u_1k r_width=1u r_length=12.5u
X517 VSS a_41684_232275# a_41684_232275# VSS nfet_06v0 ad=13p pd=50.52u as=13p ps=50.52u w=50u l=0.7u
X518 a_41684_232275# a_41684_220611# a_41684_220611# VSS nfet_06v0 ad=13p pd=50.52u as=13p ps=50.52u w=50u l=0.7u
X519 a_41684_220611# ESD_RAIL ESD_RAIL VSS nfet_06v0 ad=13p pd=50.52u as=13p ps=50.52u w=50u l=0.7u
X520 VDD FS_P_GATE FS_P_WELL FS_P_WELL pfet_03v3 ad=6.16p pd=28.88u as=6.16p ps=28.88u w=14u l=0.28u
D10 VSS ESD_RAIL diode_nd2ps_06v0 pj=82u area=40p
X521 VSS a_41684_232275# a_41684_232275# VSS nfet_06v0 ad=13p pd=50.52u as=13p ps=50.52u w=50u l=0.7u
X522 PULLUP_P_OUT PULLUP_P_GATE PULLUP_P_WELL PULLUP_P_WELL pfet_03v3 ad=8.8p pd=40.88u as=8.8p ps=40.88u w=20u l=0.28u
D11 VSS ESD_RAIL diode_nd2ps_06v0 pj=82u area=40p
X523 a_41684_232275# a_41684_232275# VSS VSS nfet_06v0 ad=13p pd=50.52u as=13p ps=50.52u w=50u l=0.7u
X524 VSS a_41684_232275# a_41684_232275# VSS nfet_06v0 ad=13p pd=50.52u as=13p ps=50.52u w=50u l=0.7u
X525 a_41684_232275# a_41684_232275# VSS VSS nfet_06v0 ad=13p pd=50.52u as=13p ps=50.52u w=50u l=0.7u
X526 VSS a_41684_232275# a_41684_232275# VSS nfet_06v0 ad=13p pd=50.52u as=13p ps=50.52u w=50u l=0.7u
X527 TERM_N_R TERM_GATE_N TERM_VCM VSS nfet_03v3 ad=8.8p pd=40.88u as=8.8p ps=40.88u w=20u l=0.28u
X528 a_41684_220611# ESD_RAIL ESD_RAIL VSS nfet_06v0 ad=13p pd=50.52u as=13p ps=50.52u w=50u l=0.7u
X529 ESD_RAIL a_42245_162628# VSS VSS nfet_06v0 ad=13p pd=50.52u as=13p ps=50.52u w=50u l=0.7u
X530 a_41684_232275# a_41684_232275# VSS VSS nfet_06v0 ad=13p pd=50.52u as=13p ps=50.52u w=50u l=0.7u
X531 VSS a_41684_232275# a_41684_232275# VSS nfet_06v0 ad=13p pd=50.52u as=13p ps=50.52u w=50u l=0.7u
X532 HS_P_12 HS_P PAD_P VSS nfet_06v0 ad=8.8p pd=40.88u as=8.8p ps=40.88u w=20u l=0.7u
X533 ESD_RAIL a_42245_162628# VSS VSS nfet_06v0 ad=13p pd=50.52u as=13p ps=50.52u w=50u l=0.7u
X534 FS_N_OUT FS_N_GATE FS_N_WELL FS_N_WELL pfet_03v3 ad=6.16p pd=28.88u as=6.16p ps=28.88u w=14u l=0.28u
X535 a_41684_232275# a_41684_220611# a_41684_220611# VSS nfet_06v0 ad=13p pd=50.52u as=13p ps=50.52u w=50u l=0.7u
X536 a_41684_232275# a_41684_232275# VSS VSS nfet_06v0 ad=13p pd=50.52u as=13p ps=50.52u w=50u l=0.7u
X537 VSS a_41684_232275# a_41684_232275# VSS nfet_06v0 ad=13p pd=50.52u as=13p ps=50.52u w=50u l=0.7u
X538 PAD_N TERM_N_R VSS ppolyf_u r_width=16u r_length=1.3u
X539 a_41684_232275# a_41684_232275# VSS VSS nfet_06v0 ad=13p pd=50.52u as=13p ps=50.52u w=50u l=0.7u
X540 HS_N_1 HS_PBIAS VDD VDD pfet_03v3 ad=8.8p pd=40.88u as=8.8p ps=40.88u w=20u l=1u
X541 a_41684_220611# a_41684_220611# a_41684_232275# VSS nfet_06v0 ad=13p pd=50.52u as=13p ps=50.52u w=50u l=0.7u
X542 ESD_RAIL ESD_RAIL a_41684_220611# VSS nfet_06v0 ad=13p pd=50.52u as=13p ps=50.52u w=50u l=0.7u
X543 PULLUP_N_GATE PULLUP_N PULLUP_N_CONTROL_S VSS nfet_06v0 ad=0.88p pd=4.88u as=0.88p ps=4.88u w=2u l=0.7u
X544 VSS a_41684_232275# a_41684_232275# VSS nfet_06v0 ad=13p pd=50.52u as=13p ps=50.52u w=50u l=0.7u
X545 FS_N_BLEED_1 FS_N_BLEED_2 VSS ppolyf_u_1k r_width=1u r_length=12.5u
X546 a_41684_232275# a_41684_232275# VSS VSS nfet_06v0 ad=13p pd=50.52u as=13p ps=50.52u w=50u l=0.7u
X547 ESD_RAIL ESD_RAIL a_41684_220611# VSS nfet_06v0 ad=13p pd=50.52u as=13p ps=50.52u w=50u l=0.7u
X548 DIV_N DIV_ENABLE RX_N VSS nfet_06v0 ad=8.8p pd=40.88u as=8.8p ps=40.88u w=20u l=0.7u
X549 TERM_OR_N_B VCM_LOW_OK TERM_OR_N_S VDD pfet_03v3 ad=1.76p pd=8.88u as=1.76p ps=8.88u w=4u l=0.28u
X550 a_41684_232275# a_41684_232275# VSS VSS nfet_06v0 ad=13p pd=50.52u as=13p ps=50.52u w=50u l=0.7u
X551 a_41005_203825# a_53878_203545# ESD_RAIL ppolyf_u r_width=0.8u r_length=63.855u
X552 FS_P_GATE FS_HIGH_P FS_P_CONTROL_S VSS nfet_06v0 ad=0.88p pd=4.88u as=0.88p ps=4.88u w=2u l=0.7u
X553 VSS a_41684_232275# a_41684_232275# VSS nfet_06v0 ad=13p pd=50.52u as=13p ps=50.52u w=50u l=0.7u
X554 a_41684_232275# a_41684_232275# VSS VSS nfet_06v0 ad=13p pd=50.52u as=13p ps=50.52u w=50u l=0.7u
X555 a_41684_232275# a_41684_232275# VSS VSS nfet_06v0 ad=13p pd=50.52u as=13p ps=50.52u w=50u l=0.7u
X556 ESD_RAIL ESD_RAIL a_41684_220611# VSS nfet_06v0 ad=13p pd=50.52u as=13p ps=50.52u w=50u l=0.7u
X557 HS_P_10 HS_PBIAS VDD VDD pfet_03v3 ad=8.8p pd=40.88u as=8.8p ps=40.88u w=20u l=1u
X558 VDD FS_P_GATE FS_P_WELL FS_P_WELL pfet_03v3 ad=6.16p pd=28.88u as=6.16p ps=28.88u w=14u l=0.28u
X559 VSS a_41684_232275# a_41684_232275# VSS nfet_06v0 ad=13p pd=50.52u as=13p ps=50.52u w=50u l=0.7u
X560 a_44789_189064# a_43813_189064# VSS VSS nfet_06v0 ad=1.3p pd=5.52u as=2.2p ps=10.88u w=5u l=0.7u
X561 a_41684_232275# a_41684_232275# VSS VSS nfet_06v0 ad=13p pd=50.52u as=13p ps=50.52u w=50u l=0.7u
X562 TERM_N_R TERM_GATE_N TERM_VCM VSS nfet_03v3 ad=8.8p pd=40.88u as=8.8p ps=40.88u w=20u l=0.28u
X563 VSS RX_P VSS ppolyf_u_1k_6p0 r_width=1u r_length=0.31954m
X564 VSS a_41684_232275# a_41684_232275# VSS nfet_06v0 ad=13p pd=50.52u as=13p ps=50.52u w=50u l=0.7u
X565 a_41684_220611# ESD_RAIL ESD_RAIL VSS nfet_06v0 ad=13p pd=50.52u as=13p ps=50.52u w=50u l=0.7u
X566 a_41684_232275# a_41684_232275# VSS VSS nfet_06v0 ad=13p pd=50.52u as=13p ps=50.52u w=50u l=0.7u
X567 VSS a_41684_232275# a_41684_232275# VSS nfet_06v0 ad=13p pd=50.52u as=13p ps=50.52u w=50u l=0.7u
X568 a_41684_220611# ESD_RAIL ESD_RAIL VSS nfet_06v0 ad=13p pd=50.52u as=13p ps=50.52u w=50u l=0.7u
X569 VDD FS_P_GATE FS_P_WELL FS_P_WELL pfet_03v3 ad=6.16p pd=28.88u as=6.16p ps=28.88u w=14u l=0.28u
X570 VSS a_41684_232275# a_41684_232275# VSS nfet_06v0 ad=13p pd=50.52u as=13p ps=50.52u w=50u l=0.7u
X571 a_41684_220611# ESD_RAIL ESD_RAIL VSS nfet_06v0 ad=13p pd=50.52u as=13p ps=50.52u w=50u l=0.7u
X572 VSS a_42245_162628# ESD_RAIL VSS nfet_06v0 ad=13p pd=50.52u as=13p ps=50.52u w=50u l=0.7u
X573 PULLUP_N_OUT PAD_N VSS ppolyf_u_1k r_width=1u r_length=1.18u
X574 VDD FS_P_GATE FS_P_WELL FS_P_WELL pfet_03v3 ad=6.16p pd=28.88u as=6.16p ps=28.88u w=14u l=0.28u
X575 VSS a_42245_162628# ESD_RAIL VSS nfet_06v0 ad=13p pd=50.52u as=13p ps=50.52u w=50u l=0.7u
X576 a_41684_232275# a_41684_232275# VSS VSS nfet_06v0 ad=13p pd=50.52u as=13p ps=50.52u w=50u l=0.7u
X577 VSS a_41684_232275# a_41684_232275# VSS nfet_06v0 ad=13p pd=50.52u as=13p ps=50.52u w=50u l=0.7u
X578 a_41684_232275# a_41684_220611# a_41684_220611# VSS nfet_06v0 ad=13p pd=50.52u as=13p ps=50.52u w=50u l=0.7u
X579 VSS a_41684_232275# a_41684_232275# VSS nfet_06v0 ad=13p pd=50.52u as=13p ps=50.52u w=50u l=0.7u
X580 VSS a_42245_162628# ESD_RAIL VSS nfet_06v0 ad=13p pd=50.52u as=13p ps=50.52u w=50u l=0.7u
X581 VDD FS_P_GATE FS_P_WELL FS_P_WELL pfet_03v3 ad=6.16p pd=28.88u as=6.16p ps=28.88u w=14u l=0.28u
X582 FS_N_WELL FS_N_BLEED_0 VSS ppolyf_u_1k r_width=1u r_length=12.5u
X583 VSS a_41684_232275# a_41684_232275# VSS nfet_06v0 ad=13p pd=50.52u as=13p ps=50.52u w=50u l=0.7u
X584 ESD_RAIL ESD_RAIL a_41684_220611# VSS nfet_06v0 ad=13p pd=50.52u as=13p ps=50.52u w=50u l=0.7u
X585 ESD_RAIL ESD_RAIL a_41684_220611# VSS nfet_06v0 ad=13p pd=50.52u as=13p ps=50.52u w=50u l=0.7u
X586 PULLUP_N_GATE VDD PULLUP_N_WELL PULLUP_N_WELL pfet_03v3 ad=1.76p pd=8.88u as=1.76p ps=8.88u w=4u l=0.28u
X587 a_41684_220611# a_41684_220611# a_41684_232275# VSS nfet_06v0 ad=13p pd=50.52u as=13p ps=50.52u w=50u l=0.7u
X588 VSS a_41684_232275# a_41684_232275# VSS nfet_06v0 ad=13p pd=50.52u as=13p ps=50.52u w=50u l=0.7u
X589 FS_N_OUT FS_N_GATE FS_N_WELL FS_N_WELL pfet_03v3 ad=6.16p pd=28.88u as=6.16p ps=28.88u w=14u l=0.28u
X590 ESD_RAIL ESD_RAIL a_41684_220611# VSS nfet_06v0 ad=13p pd=50.52u as=13p ps=50.52u w=50u l=0.7u
X591 a_41005_204945# a_53878_204665# ESD_RAIL ppolyf_u r_width=0.8u r_length=63.855u
X592 PULLUP_P_WELL PULLUP_P_BLEED_0 VSS ppolyf_u_1k r_width=1u r_length=12.5u
X593 ESD_RAIL ESD_RAIL a_41684_220611# VSS nfet_06v0 ad=13p pd=50.52u as=13p ps=50.52u w=50u l=0.7u
X594 a_41684_220611# a_41684_220611# a_41684_232275# VSS nfet_06v0 ad=13p pd=50.52u as=13p ps=50.52u w=50u l=0.7u
X595 HS_P_6 HS_PBIAS VDD VDD pfet_03v3 ad=8.8p pd=40.88u as=8.8p ps=40.88u w=20u l=1u
X596 VDD FS_N_GATE FS_N_WELL FS_N_WELL pfet_03v3 ad=6.16p pd=28.88u as=6.16p ps=28.88u w=14u l=0.28u
X597 a_41684_220611# ESD_RAIL ESD_RAIL VSS nfet_06v0 ad=13p pd=50.52u as=13p ps=50.52u w=50u l=0.7u
X598 a_41684_232275# a_41684_220611# a_41684_220611# VSS nfet_06v0 ad=13p pd=50.52u as=13p ps=50.52u w=50u l=0.7u
X599 a_41684_220611# ESD_RAIL ESD_RAIL VSS nfet_06v0 ad=13p pd=50.52u as=13p ps=50.52u w=50u l=0.7u
X600 ESD_RAIL ESD_RAIL a_41684_220611# VSS nfet_06v0 ad=13p pd=50.52u as=13p ps=50.52u w=50u l=0.7u
X601 a_41684_220611# a_41684_220611# a_41684_232275# VSS nfet_06v0 ad=13p pd=50.52u as=13p ps=50.52u w=50u l=0.7u
X602 a_41684_232275# a_41684_220611# a_41684_220611# VSS nfet_06v0 ad=13p pd=50.52u as=13p ps=50.52u w=50u l=0.7u
X603 a_41684_220611# a_41684_220611# a_41684_232275# VSS nfet_06v0 ad=13p pd=50.52u as=13p ps=50.52u w=50u l=0.7u
X604 VDD FS_N_GATE FS_N_WELL FS_N_WELL pfet_03v3 ad=6.16p pd=28.88u as=6.16p ps=28.88u w=14u l=0.28u
X605 a_41684_220611# ESD_RAIL ESD_RAIL VSS nfet_06v0 ad=13p pd=50.52u as=13p ps=50.52u w=50u l=0.7u
X606 a_41684_220611# ESD_RAIL ESD_RAIL VSS nfet_06v0 ad=13p pd=50.52u as=13p ps=50.52u w=50u l=0.7u
X607 a_41684_232275# a_41684_232275# VSS VSS nfet_06v0 ad=13p pd=50.52u as=13p ps=50.52u w=50u l=0.7u
X608 ESD_RAIL ESD_RAIL a_41684_220611# VSS nfet_06v0 ad=13p pd=50.52u as=13p ps=50.52u w=50u l=0.7u
X609 ESD_RAIL a_42245_162628# VSS VSS nfet_06v0 ad=13p pd=50.52u as=13p ps=50.52u w=50u l=0.7u
X610 VDD FS_P_GATE FS_P_WELL FS_P_WELL pfet_03v3 ad=6.16p pd=28.88u as=6.16p ps=28.88u w=14u l=0.28u
X611 a_41684_220611# ESD_RAIL ESD_RAIL VSS nfet_06v0 ad=13p pd=50.52u as=13p ps=50.52u w=50u l=0.7u
X612 a_41684_232275# a_41684_220611# a_41684_220611# VSS nfet_06v0 ad=13p pd=50.52u as=13p ps=50.52u w=50u l=0.7u
X613 VSS a_41684_232275# a_41684_232275# VSS nfet_06v0 ad=13p pd=50.52u as=13p ps=50.52u w=50u l=0.7u
X614 a_41684_220611# ESD_RAIL ESD_RAIL VSS nfet_06v0 ad=13p pd=50.52u as=13p ps=50.52u w=50u l=0.7u
X615 a_41684_220611# ESD_RAIL ESD_RAIL VSS nfet_06v0 ad=13p pd=50.52u as=13p ps=50.52u w=50u l=0.7u
X616 ESD_RAIL ESD_RAIL a_41684_220611# VSS nfet_06v0 ad=13p pd=50.52u as=13p ps=50.52u w=50u l=0.7u
X617 HS_P_12 HS_PBIAS VDD VDD pfet_03v3 ad=8.8p pd=40.88u as=8.8p ps=40.88u w=20u l=1u
X618 VDD FS_P_GATE FS_P_WELL FS_P_WELL pfet_03v3 ad=6.16p pd=28.88u as=6.16p ps=28.88u w=14u l=0.28u
X619 a_41684_232275# a_41684_232275# VSS VSS nfet_06v0 ad=13p pd=50.52u as=13p ps=50.52u w=50u l=0.7u
X620 ESD_RAIL a_42245_162628# VSS VSS nfet_06v0 ad=13p pd=50.52u as=13p ps=50.52u w=50u l=0.7u
X621 a_41684_232275# a_41684_220611# a_41684_220611# VSS nfet_06v0 ad=13p pd=50.52u as=13p ps=50.52u w=50u l=0.7u
X622 a_41684_220611# a_41684_220611# a_41684_232275# VSS nfet_06v0 ad=13p pd=50.52u as=13p ps=50.52u w=50u l=0.7u
X623 TERM_P_R DIFF_ENABLE TERM_N_R VSS nfet_03v3 ad=8.8p pd=40.88u as=8.8p ps=40.88u w=20u l=0.28u
X624 VSS a_41684_232275# a_41684_232275# VSS nfet_06v0 ad=13p pd=50.52u as=13p ps=50.52u w=50u l=0.7u
X625 VSS a_42245_162628# ESD_RAIL VSS nfet_06v0 ad=13p pd=50.52u as=13p ps=50.52u w=50u l=0.7u
X626 ESD_RAIL ESD_RAIL a_41684_220611# VSS nfet_06v0 ad=13p pd=50.52u as=13p ps=50.52u w=50u l=0.7u
X627 TERM_GATE_N_BLEED_0 TERM_GATE_N_BLEED_1 VSS ppolyf_u_1k r_width=1u r_length=12.5u
X628 a_41684_220611# ESD_RAIL ESD_RAIL VSS nfet_06v0 ad=13p pd=50.52u as=13p ps=50.52u w=50u l=0.7u
X629 a_41684_232275# a_41684_220611# a_41684_220611# VSS nfet_06v0 ad=13p pd=50.52u as=13p ps=50.52u w=50u l=0.7u
X630 a_41684_220611# a_41684_220611# a_41684_232275# VSS nfet_06v0 ad=13p pd=50.52u as=13p ps=50.52u w=50u l=0.7u
X631 ESD_RAIL ESD_RAIL a_41684_220611# VSS nfet_06v0 ad=13p pd=50.52u as=13p ps=50.52u w=50u l=0.7u
X632 ESD_RAIL a_44789_189064# a_42245_162628# ESD_RAIL pfet_06v0 ad=1.3p pd=5.52u as=1.3p ps=5.52u w=5u l=0.7u
X633 PULLUP_P_BLEED_3 PULLUP_P_BLEED_4 VSS ppolyf_u_1k r_width=1u r_length=12.5u
X634 VSS a_41684_232275# a_41684_232275# VSS nfet_06v0 ad=13p pd=50.52u as=13p ps=50.52u w=50u l=0.7u
X635 a_41684_220611# ESD_RAIL ESD_RAIL VSS nfet_06v0 ad=13p pd=50.52u as=13p ps=50.52u w=50u l=0.7u
X636 VDD FS_N_GATE FS_N_WELL FS_N_WELL pfet_03v3 ad=6.16p pd=28.88u as=6.16p ps=28.88u w=14u l=0.28u
X637 a_41684_220611# a_41684_220611# a_41684_232275# VSS nfet_06v0 ad=13p pd=50.52u as=13p ps=50.52u w=50u l=0.7u
X638 a_41684_232275# a_41684_232275# VSS VSS nfet_06v0 ad=13p pd=50.52u as=13p ps=50.52u w=50u l=0.7u
X639 a_41684_232275# a_41684_232275# VSS VSS nfet_06v0 ad=13p pd=50.52u as=13p ps=50.52u w=50u l=0.7u
X640 VDD FS_P_GATE FS_P_WELL FS_P_WELL pfet_03v3 ad=6.16p pd=28.88u as=6.16p ps=28.88u w=14u l=0.28u
X641 VSS a_41684_232275# a_41684_232275# VSS nfet_06v0 ad=13p pd=50.52u as=13p ps=50.52u w=50u l=0.7u
X642 a_41684_220611# ESD_RAIL ESD_RAIL VSS nfet_06v0 ad=13p pd=50.52u as=13p ps=50.52u w=50u l=0.7u
X643 VDD FS_N_GATE FS_N_WELL FS_N_WELL pfet_03v3 ad=6.16p pd=28.88u as=6.16p ps=28.88u w=14u l=0.28u
X644 VSS a_41684_232275# a_41684_232275# VSS nfet_06v0 ad=13p pd=50.52u as=13p ps=50.52u w=50u l=0.7u
X645 ESD_RAIL ESD_RAIL a_41684_220611# VSS nfet_06v0 ad=13p pd=50.52u as=13p ps=50.52u w=50u l=0.7u
X646 TERM_GATE_P TERM_OR_P_B VSS VSS nfet_03v3 ad=1.76p pd=8.88u as=1.76p ps=8.88u w=4u l=0.28u
X647 HS_N_12 HS_PBIAS VDD VDD pfet_03v3 ad=8.8p pd=40.88u as=8.8p ps=40.88u w=20u l=1u
X648 a_41684_220611# a_41684_220611# a_41684_232275# VSS nfet_06v0 ad=13p pd=50.52u as=13p ps=50.52u w=50u l=0.7u
X649 a_41684_232275# a_41684_220611# a_41684_220611# VSS nfet_06v0 ad=13p pd=50.52u as=13p ps=50.52u w=50u l=0.7u
X650 HS_N_8 HS_N PAD_N VSS nfet_06v0 ad=8.8p pd=40.88u as=8.8p ps=40.88u w=20u l=0.7u
X651 a_41684_232275# a_41684_232275# VSS VSS nfet_06v0 ad=13p pd=50.52u as=22p ps=0.10088m w=50u l=0.7u
X652 a_41684_220611# ESD_RAIL ESD_RAIL VSS nfet_06v0 ad=13p pd=50.52u as=13p ps=50.52u w=50u l=0.7u
X653 PULLUP_N_BLEED_4 PULLUP_N_BLEED_5 VSS ppolyf_u_1k r_width=1u r_length=12.5u
X654 ESD_RAIL ESD_RAIL a_41684_220611# VSS nfet_06v0 ad=13p pd=50.52u as=13p ps=50.52u w=50u l=0.7u
X655 a_41684_232275# a_41684_220611# a_41684_220611# VSS nfet_06v0 ad=13p pd=50.52u as=13p ps=50.52u w=50u l=0.7u
X656 a_41684_220611# a_41684_220611# a_41684_232275# VSS nfet_06v0 ad=13p pd=50.52u as=13p ps=50.52u w=50u l=0.7u
X657 a_41684_232275# a_41684_220611# a_41684_220611# VSS nfet_06v0 ad=13p pd=50.52u as=13p ps=50.52u w=50u l=0.7u
X658 VSS a_42245_162628# ESD_RAIL VSS nfet_06v0 ad=13p pd=50.52u as=13p ps=50.52u w=50u l=0.7u
X659 VSS a_41684_232275# a_41684_232275# VSS nfet_06v0 ad=13p pd=50.52u as=13p ps=50.52u w=50u l=0.7u
X660 a_41684_232275# a_41684_232275# VSS VSS nfet_06v0 ad=13p pd=50.52u as=13p ps=50.52u w=50u l=0.7u
X661 a_41684_232275# a_41684_232275# VSS VSS nfet_06v0 ad=13p pd=50.52u as=13p ps=50.52u w=50u l=0.7u
X662 TERM_OR_P_B FS_LOW_P TERM_OR_P_S VDD pfet_03v3 ad=1.76p pd=8.88u as=1.76p ps=8.88u w=4u l=0.28u
X663 VSS a_42245_162628# ESD_RAIL VSS nfet_06v0 ad=13p pd=50.52u as=22p ps=0.10088m w=50u l=0.7u
X664 a_41684_232275# a_41684_220611# a_41684_220611# VSS nfet_06v0 ad=13p pd=50.52u as=13p ps=50.52u w=50u l=0.7u
X665 VSS a_42245_162628# ESD_RAIL VSS nfet_06v0 ad=13p pd=50.52u as=13p ps=50.52u w=50u l=0.7u
X666 VSS a_41684_232275# a_41684_232275# VSS nfet_06v0 ad=13p pd=50.52u as=13p ps=50.52u w=50u l=0.7u
X667 VDD FS_N_GATE FS_N_WELL FS_N_WELL pfet_03v3 ad=6.16p pd=28.88u as=6.16p ps=28.88u w=14u l=0.28u
X668 a_41684_232275# a_41684_232275# VSS VSS nfet_06v0 ad=13p pd=50.52u as=13p ps=50.52u w=50u l=0.7u
X669 ESD_RAIL ESD_RAIL a_41684_220611# VSS nfet_06v0 ad=13p pd=50.52u as=13p ps=50.52u w=50u l=0.7u
X670 a_41684_220611# ESD_RAIL ESD_RAIL VSS nfet_06v0 ad=13p pd=50.52u as=13p ps=50.52u w=50u l=0.7u
X671 VSS a_42245_162628# ESD_RAIL VSS nfet_06v0 ad=13p pd=50.52u as=22p ps=0.10088m w=50u l=0.7u
X672 a_43813_189064# a_41005_203545# ESD_RAIL ESD_RAIL pfet_06v0 ad=1.3p pd=5.52u as=1.3p ps=5.52u w=5u l=0.7u
X673 a_41684_232275# a_41684_220611# a_41684_220611# VSS nfet_06v0 ad=13p pd=50.52u as=13p ps=50.52u w=50u l=0.7u
X674 a_41684_220611# a_41684_220611# a_41684_232275# VSS nfet_06v0 ad=13p pd=50.52u as=13p ps=50.52u w=50u l=0.7u
X675 a_42245_162628# a_44789_189064# ESD_RAIL ESD_RAIL pfet_06v0 ad=1.3p pd=5.52u as=1.3p ps=5.52u w=5u l=0.7u
X676 a_41684_232275# a_41684_232275# VSS VSS nfet_06v0 ad=13p pd=50.52u as=13p ps=50.52u w=50u l=0.7u
X677 VSS a_41684_232275# a_41684_232275# VSS nfet_06v0 ad=13p pd=50.52u as=13p ps=50.52u w=50u l=0.7u
X678 TERM_GATE_P TERM_OR_P_B VDD VDD pfet_03v3 ad=3.52p pd=16.88u as=3.52p ps=16.88u w=8u l=0.28u
X679 a_41684_220611# a_41684_220611# a_41684_232275# VSS nfet_06v0 ad=13p pd=50.52u as=13p ps=50.52u w=50u l=0.7u
X680 a_41684_220611# a_41684_220611# a_41684_232275# VSS nfet_06v0 ad=13p pd=50.52u as=13p ps=50.52u w=50u l=0.7u
X681 VSS RX_N VSS ppolyf_u_1k_6p0 r_width=1u r_length=0.31954m
X682 a_41684_232275# a_41684_232275# VSS VSS nfet_06v0 ad=13p pd=50.52u as=13p ps=50.52u w=50u l=0.7u
X683 HS_N_10 HS_PBIAS VDD VDD pfet_03v3 ad=8.8p pd=40.88u as=8.8p ps=40.88u w=20u l=1u
X684 VSS a_41684_232275# a_41684_232275# VSS nfet_06v0 ad=13p pd=50.52u as=13p ps=50.52u w=50u l=0.7u
X685 a_41684_220611# a_41684_220611# a_41684_232275# VSS nfet_06v0 ad=13p pd=50.52u as=13p ps=50.52u w=50u l=0.7u
X686 a_41005_203545# VSS cap_mim_2f0_m4m5_noshield c_width=31.6u c_length=31.6u
X687 a_41684_220611# ESD_RAIL ESD_RAIL VSS nfet_06v0 ad=13p pd=50.52u as=13p ps=50.52u w=50u l=0.7u
X688 VSS a_41684_232275# a_41684_232275# VSS nfet_06v0 ad=13p pd=50.52u as=13p ps=50.52u w=50u l=0.7u
X689 TERM_OR_P_B FS_LOW_P TERM_OR_P_NS VSS nfet_03v3 ad=0.88p pd=4.88u as=0.88p ps=4.88u w=2u l=0.28u
X690 ESD_RAIL ESD_RAIL a_41684_220611# VSS nfet_06v0 ad=13p pd=50.52u as=13p ps=50.52u w=50u l=0.7u
X691 FS_N_BLEED_3 FS_N_BLEED_4 VSS ppolyf_u_1k r_width=1u r_length=12.5u
X692 a_41684_220611# a_41684_220611# a_41684_232275# VSS nfet_06v0 ad=13p pd=50.52u as=13p ps=50.52u w=50u l=0.7u
X693 a_41684_232275# a_41684_232275# VSS VSS nfet_06v0 ad=13p pd=50.52u as=13p ps=50.52u w=50u l=0.7u
X694 VSS a_41684_232275# a_41684_232275# VSS nfet_06v0 ad=13p pd=50.52u as=13p ps=50.52u w=50u l=0.7u
X695 a_41684_232275# a_41684_232275# VSS VSS nfet_06v0 ad=13p pd=50.52u as=13p ps=50.52u w=50u l=0.7u
X696 VSS a_42245_162628# ESD_RAIL VSS nfet_06v0 ad=13p pd=50.52u as=13p ps=50.52u w=50u l=0.7u
X697 a_44789_189064# a_43813_189064# ESD_RAIL ESD_RAIL pfet_06v0 ad=2.2p pd=10.88u as=1.3p ps=5.52u w=5u l=0.7u
X698 a_41005_206065# a_53878_205785# ESD_RAIL ppolyf_u r_width=0.8u r_length=63.855u
X699 a_41684_232275# a_41684_232275# VSS VSS nfet_06v0 ad=13p pd=50.52u as=13p ps=50.52u w=50u l=0.7u
X700 PULLUP_N_BLEED_0 PULLUP_N_BLEED_1 VSS ppolyf_u_1k r_width=1u r_length=12.5u
X701 FS_P_BLEED_4 FS_P_BLEED_5 VSS ppolyf_u_1k r_width=1u r_length=12.5u
D12 VSS PAD_N diode_nd2ps_06v0 pj=51.8u area=22.5p
X702 ESD_RAIL a_42245_162628# VSS VSS nfet_06v0 ad=13p pd=50.52u as=13p ps=50.52u w=50u l=0.7u
X703 FS_P_OUT FS_P_GATE FS_P_WELL FS_P_WELL pfet_03v3 ad=6.16p pd=28.88u as=6.16p ps=28.88u w=14u l=0.28u
X704 VSS a_41684_232275# a_41684_232275# VSS nfet_06v0 ad=13p pd=50.52u as=13p ps=50.52u w=50u l=0.7u
X705 a_41684_232275# a_41684_232275# VSS VSS nfet_06v0 ad=13p pd=50.52u as=13p ps=50.52u w=50u l=0.7u
X706 VDD PULLUP_P_GATE PULLUP_P_WELL PULLUP_P_WELL pfet_03v3 ad=8.8p pd=40.88u as=8.8p ps=40.88u w=20u l=0.28u
X707 FS_N_BLEED_5 FS_N_BLEED_6 VSS ppolyf_u_1k r_width=1u r_length=12.5u
X708 a_41684_232275# a_41684_232275# VSS VSS nfet_06v0 ad=13p pd=50.52u as=13p ps=50.52u w=50u l=0.7u
X709 VDD FS_N_GATE FS_N_WELL FS_N_WELL pfet_03v3 ad=6.16p pd=28.88u as=6.16p ps=28.88u w=14u l=0.28u
X710 VSS a_41684_232275# a_41684_232275# VSS nfet_06v0 ad=13p pd=50.52u as=13p ps=50.52u w=50u l=0.7u
X711 a_41684_232275# a_41684_232275# VSS VSS nfet_06v0 ad=13p pd=50.52u as=13p ps=50.52u w=50u l=0.7u
X712 HS_N_1 HS_N PAD_N VSS nfet_06v0 ad=8.8p pd=40.88u as=8.8p ps=40.88u w=20u l=0.7u
X713 a_41684_232275# a_41684_232275# VSS VSS nfet_06v0 ad=13p pd=50.52u as=13p ps=50.52u w=50u l=0.7u
X714 VSS a_41684_232275# a_41684_232275# VSS nfet_06v0 ad=13p pd=50.52u as=13p ps=50.52u w=50u l=0.7u
X715 a_41684_232275# a_41684_232275# VSS VSS nfet_06v0 ad=13p pd=50.52u as=13p ps=50.52u w=50u l=0.7u
X716 HS_N_4 HS_PBIAS VDD VDD pfet_03v3 ad=8.8p pd=40.88u as=8.8p ps=40.88u w=20u l=1u
X717 FS_N_GATE FS_HIGH_N FS_N_CONTROL_S VSS nfet_06v0 ad=0.88p pd=4.88u as=0.88p ps=4.88u w=2u l=0.7u
X718 VSS a_41684_232275# a_41684_232275# VSS nfet_06v0 ad=13p pd=50.52u as=13p ps=50.52u w=50u l=0.7u
X719 VDD FS_N_GATE FS_N_WELL FS_N_WELL pfet_03v3 ad=6.16p pd=28.88u as=6.16p ps=28.88u w=14u l=0.28u
X720 a_41684_232275# a_41684_232275# VSS VSS nfet_06v0 ad=13p pd=50.52u as=13p ps=50.52u w=50u l=0.7u
X721 a_41684_220611# a_41684_220611# a_41684_232275# VSS nfet_06v0 ad=13p pd=50.52u as=13p ps=50.52u w=50u l=0.7u
X722 a_41684_232275# a_41684_232275# VSS VSS nfet_06v0 ad=13p pd=50.52u as=13p ps=50.52u w=50u l=0.7u
X723 ESD_RAIL a_44789_189064# a_42245_162628# ESD_RAIL pfet_06v0 ad=2.2p pd=10.88u as=1.3p ps=5.52u w=5u l=0.7u
X724 a_42245_162628# a_44789_189064# ESD_RAIL ESD_RAIL pfet_06v0 ad=1.3p pd=5.52u as=1.3p ps=5.52u w=5u l=0.7u
X725 VSS a_41684_232275# a_41684_232275# VSS nfet_06v0 ad=13p pd=50.52u as=13p ps=50.52u w=50u l=0.7u
X726 VSS a_42245_162628# ESD_RAIL VSS nfet_06v0 ad=13p pd=50.52u as=13p ps=50.52u w=50u l=0.7u
X727 TERM_GATE_N TERM_OR_N_B VSS VSS nfet_03v3 ad=1.76p pd=8.88u as=1.76p ps=8.88u w=4u l=0.28u
X728 a_41684_220611# ESD_RAIL ESD_RAIL VSS nfet_06v0 ad=13p pd=50.52u as=13p ps=50.52u w=50u l=0.7u
X729 a_41684_232275# a_41684_232275# VSS VSS nfet_06v0 ad=13p pd=50.52u as=13p ps=50.52u w=50u l=0.7u
X730 a_41684_220611# a_41684_220611# a_41684_232275# VSS nfet_06v0 ad=13p pd=50.52u as=13p ps=50.52u w=50u l=0.7u
D13 VSS PAD_P diode_nd2ps_06v0 pj=51.8u area=22.5p
X731 a_41684_232275# a_41684_220611# a_41684_220611# VSS nfet_06v0 ad=13p pd=50.52u as=13p ps=50.52u w=50u l=0.7u
X732 HS_N_10 HS_N PAD_N VSS nfet_06v0 ad=8.8p pd=40.88u as=8.8p ps=40.88u w=20u l=0.7u
X733 VSS a_41684_232275# a_41684_232275# VSS nfet_06v0 ad=13p pd=50.52u as=13p ps=50.52u w=50u l=0.7u
X734 a_41684_232275# a_41684_232275# VSS VSS nfet_06v0 ad=13p pd=50.52u as=13p ps=50.52u w=50u l=0.7u
X735 a_41684_220611# a_41684_220611# a_41684_232275# VSS nfet_06v0 ad=13p pd=50.52u as=13p ps=50.52u w=50u l=0.7u
X736 ESD_RAIL ESD_RAIL a_41684_220611# VSS nfet_06v0 ad=13p pd=50.52u as=13p ps=50.52u w=50u l=0.7u
X737 TERM_P_R TERM_GATE_P TERM_VCM VSS nfet_03v3 ad=8.8p pd=40.88u as=8.8p ps=40.88u w=20u l=0.28u
X738 PAD_N BYPASS_ENABLE RX_N VSS nfet_06v0 ad=8.8p pd=40.88u as=8.8p ps=40.88u w=20u l=0.7u
X739 VDD FS_N_GATE FS_N_WELL FS_N_WELL pfet_03v3 ad=6.16p pd=28.88u as=6.16p ps=28.88u w=14u l=0.28u
X740 VSS a_41684_232275# a_41684_232275# VSS nfet_06v0 ad=13p pd=50.52u as=13p ps=50.52u w=50u l=0.7u
X741 a_41684_232275# a_41684_220611# a_41684_220611# VSS nfet_06v0 ad=13p pd=50.52u as=13p ps=50.52u w=50u l=0.7u
X742 VSS a_42245_162628# ESD_RAIL VSS nfet_06v0 ad=13p pd=50.52u as=13p ps=50.52u w=50u l=0.7u
X743 ESD_RAIL ESD_RAIL a_41684_220611# VSS nfet_06v0 ad=13p pd=50.52u as=13p ps=50.52u w=50u l=0.7u
X744 VSS a_42245_162628# ESD_RAIL VSS nfet_06v0 ad=13p pd=50.52u as=13p ps=50.52u w=50u l=0.7u
X745 ESD_RAIL a_44789_189064# a_42245_162628# ESD_RAIL pfet_06v0 ad=1.3p pd=5.52u as=1.3p ps=5.52u w=5u l=0.7u
X746 HS_N_3 HS_N PAD_N VSS nfet_06v0 ad=8.8p pd=40.88u as=8.8p ps=40.88u w=20u l=0.7u
X747 VDD FS_N_GATE FS_N_WELL FS_N_WELL pfet_03v3 ad=6.16p pd=28.88u as=6.16p ps=28.88u w=14u l=0.28u
X748 a_41684_232275# a_41684_220611# a_41684_220611# VSS nfet_06v0 ad=13p pd=50.52u as=13p ps=50.52u w=50u l=0.7u
X749 a_41684_220611# a_41684_220611# a_41684_232275# VSS nfet_06v0 ad=13p pd=50.52u as=13p ps=50.52u w=50u l=0.7u
X750 a_41684_220611# ESD_RAIL ESD_RAIL VSS nfet_06v0 ad=13p pd=50.52u as=13p ps=50.52u w=50u l=0.7u
X751 ESD_RAIL ESD_RAIL a_41684_220611# VSS nfet_06v0 ad=13p pd=50.52u as=13p ps=50.52u w=50u l=0.7u
X752 PULLUP_N_OUT PULLUP_N_GATE PULLUP_N_WELL PULLUP_N_WELL pfet_03v3 ad=8.8p pd=40.88u as=8.8p ps=40.88u w=20u l=0.28u
X753 VDD FS_N_GATE FS_N_WELL FS_N_WELL pfet_03v3 ad=6.16p pd=28.88u as=6.16p ps=28.88u w=14u l=0.28u
X754 VSS a_41684_232275# a_41684_232275# VSS nfet_06v0 ad=13p pd=50.52u as=13p ps=50.52u w=50u l=0.7u
X755 a_41684_232275# a_41684_220611# a_41684_220611# VSS nfet_06v0 ad=13p pd=50.52u as=13p ps=50.52u w=50u l=0.7u
X756 a_41684_220611# ESD_RAIL ESD_RAIL VSS nfet_06v0 ad=13p pd=50.52u as=13p ps=50.52u w=50u l=0.7u
X757 FS_P_OUT FS_P_GATE FS_P_WELL FS_P_WELL pfet_03v3 ad=6.16p pd=28.88u as=6.16p ps=28.88u w=14u l=0.28u
X758 ESD_RAIL ESD_RAIL a_41684_220611# VSS nfet_06v0 ad=13p pd=50.52u as=13p ps=50.52u w=50u l=0.7u
X759 a_41684_232275# a_41684_232275# VSS VSS nfet_06v0 ad=13p pd=50.52u as=13p ps=50.52u w=50u l=0.7u
X760 a_41684_220611# a_41684_220611# a_41684_232275# VSS nfet_06v0 ad=13p pd=50.52u as=13p ps=50.52u w=50u l=0.7u
X761 ESD_RAIL a_43813_189064# a_44789_189064# ESD_RAIL pfet_06v0 ad=1.3p pd=5.52u as=1.3p ps=5.52u w=5u l=0.7u
X762 VDD FS_N_GATE FS_N_WELL FS_N_WELL pfet_03v3 ad=6.16p pd=28.88u as=6.16p ps=28.88u w=14u l=0.28u
X763 ESD_RAIL a_42245_162628# VSS VSS nfet_06v0 ad=13p pd=50.52u as=13p ps=50.52u w=50u l=0.7u
X764 VSS a_41684_232275# a_41684_232275# VSS nfet_06v0 ad=13p pd=50.52u as=13p ps=50.52u w=50u l=0.7u
X765 a_41684_232275# a_41684_220611# a_41684_220611# VSS nfet_06v0 ad=13p pd=50.52u as=13p ps=50.52u w=50u l=0.7u
X766 a_41684_220611# ESD_RAIL ESD_RAIL VSS nfet_06v0 ad=13p pd=50.52u as=13p ps=50.52u w=50u l=0.7u
X767 a_41684_220611# a_41684_220611# a_41684_232275# VSS nfet_06v0 ad=13p pd=50.52u as=13p ps=50.52u w=50u l=0.7u
X768 a_41684_232275# a_41684_232275# VSS VSS nfet_06v0 ad=13p pd=50.52u as=13p ps=50.52u w=50u l=0.7u
X769 a_41684_220611# a_41684_220611# a_41684_232275# VSS nfet_06v0 ad=13p pd=50.52u as=13p ps=50.52u w=50u l=0.7u
X770 a_41684_232275# a_41684_220611# a_41684_220611# VSS nfet_06v0 ad=13p pd=50.52u as=13p ps=50.52u w=50u l=0.7u
X771 TERM_N_R TERM_GATE_N TERM_VCM VSS nfet_03v3 ad=8.8p pd=40.88u as=8.8p ps=40.88u w=20u l=0.28u
D14 VSS PAD_N diode_nd2ps_06v0 pj=51.8u area=22.5p
X772 a_41684_220611# ESD_RAIL ESD_RAIL VSS nfet_06v0 ad=13p pd=50.52u as=13p ps=50.52u w=50u l=0.7u
X773 a_42245_162628# a_44789_189064# ESD_RAIL ESD_RAIL pfet_06v0 ad=1.3p pd=5.52u as=1.3p ps=5.52u w=5u l=0.7u
X774 ESD_RAIL a_42245_162628# VSS VSS nfet_06v0 ad=13p pd=50.52u as=13p ps=50.52u w=50u l=0.7u
X775 ESD_RAIL ESD_RAIL a_41684_220611# VSS nfet_06v0 ad=13p pd=50.52u as=13p ps=50.52u w=50u l=0.7u
X776 a_41684_220611# a_41684_220611# a_41684_232275# VSS nfet_06v0 ad=13p pd=50.52u as=13p ps=50.52u w=50u l=0.7u
X777 VDD FS_N_GATE FS_N_WELL FS_N_WELL pfet_03v3 ad=6.16p pd=28.88u as=6.16p ps=28.88u w=14u l=0.28u
X778 a_41684_232275# a_41684_220611# a_41684_220611# VSS nfet_06v0 ad=13p pd=50.52u as=13p ps=50.52u w=50u l=0.7u
X779 a_41684_220611# ESD_RAIL ESD_RAIL VSS nfet_06v0 ad=13p pd=50.52u as=13p ps=50.52u w=50u l=0.7u
X780 a_41684_220611# a_41684_220611# a_41684_232275# VSS nfet_06v0 ad=13p pd=50.52u as=13p ps=50.52u w=50u l=0.7u
X781 ESD_RAIL ESD_RAIL a_41684_220611# VSS nfet_06v0 ad=13p pd=50.52u as=13p ps=50.52u w=50u l=0.7u
X782 a_43813_189064# a_41005_203545# ESD_RAIL ESD_RAIL pfet_06v0 ad=1.3p pd=5.52u as=2.2p ps=10.88u w=5u l=0.7u
X783 VSS a_41684_232275# a_41684_232275# VSS nfet_06v0 ad=13p pd=50.52u as=13p ps=50.52u w=50u l=0.7u
X784 a_41684_232275# a_41684_220611# a_41684_220611# VSS nfet_06v0 ad=13p pd=50.52u as=13p ps=50.52u w=50u l=0.7u
X785 a_41684_220611# a_41684_220611# a_41684_232275# VSS nfet_06v0 ad=13p pd=50.52u as=13p ps=50.52u w=50u l=0.7u
X786 ESD_RAIL ESD_RAIL a_41684_220611# VSS nfet_06v0 ad=13p pd=50.52u as=13p ps=50.52u w=50u l=0.7u
X787 ESD_RAIL a_42245_162628# VSS VSS nfet_06v0 ad=22p pd=0.10088m as=13p ps=50.52u w=50u l=0.7u
X788 a_41684_232275# a_41684_232275# VSS VSS nfet_06v0 ad=13p pd=50.52u as=13p ps=50.52u w=50u l=0.7u
X789 TERM_OR_N_B FS_LOW_N TERM_OR_N_S VDD pfet_03v3 ad=1.76p pd=8.88u as=1.76p ps=8.88u w=4u l=0.28u
X790 a_41684_232275# a_41684_220611# a_41684_220611# VSS nfet_06v0 ad=13p pd=50.52u as=13p ps=50.52u w=50u l=0.7u
X791 FS_P_OUT FS_P_GATE FS_P_WELL FS_P_WELL pfet_03v3 ad=6.16p pd=28.88u as=6.16p ps=28.88u w=14u l=0.28u
X792 a_41684_220611# a_41684_220611# a_41684_232275# VSS nfet_06v0 ad=13p pd=50.52u as=13p ps=50.52u w=50u l=0.7u
X793 HS_N_0 HS_PBIAS VDD VDD pfet_03v3 ad=8.8p pd=40.88u as=8.8p ps=40.88u w=20u l=1u
X794 ESD_RAIL a_42245_162628# VSS VSS nfet_06v0 ad=13p pd=50.52u as=13p ps=50.52u w=50u l=0.7u
X795 ESD_RAIL ESD_RAIL a_41684_220611# VSS nfet_06v0 ad=13p pd=50.52u as=13p ps=50.52u w=50u l=0.7u
X796 PULLUP_P_GATE VDD PULLUP_P_WELL PULLUP_P_WELL pfet_03v3 ad=1.76p pd=8.88u as=1.76p ps=8.88u w=4u l=0.28u
X797 a_41684_232275# a_41684_220611# a_41684_220611# VSS nfet_06v0 ad=13p pd=50.52u as=13p ps=50.52u w=50u l=0.7u
X798 FS_P_OUT FS_P_GATE FS_P_WELL FS_P_WELL pfet_03v3 ad=6.16p pd=28.88u as=6.16p ps=28.88u w=14u l=0.28u
X799 a_41684_220611# ESD_RAIL ESD_RAIL VSS nfet_06v0 ad=13p pd=50.52u as=13p ps=50.52u w=50u l=0.7u
X800 a_41684_232275# a_41684_220611# a_41684_220611# VSS nfet_06v0 ad=13p pd=50.52u as=13p ps=50.52u w=50u l=0.7u
X801 HS_P_1 HS_PBIAS VDD VDD pfet_03v3 ad=8.8p pd=40.88u as=8.8p ps=40.88u w=20u l=1u
X802 a_41684_232275# a_41684_232275# VSS VSS nfet_06v0 ad=13p pd=50.52u as=13p ps=50.52u w=50u l=0.7u
X803 a_41684_220611# a_41684_220611# a_41684_232275# VSS nfet_06v0 ad=13p pd=50.52u as=13p ps=50.52u w=50u l=0.7u
X804 PULLUP_P_BLEED_0 PULLUP_P_BLEED_1 VSS ppolyf_u_1k r_width=1u r_length=12.5u
X805 PULLUP_N_CONTROL_S VDD VSS VSS nfet_03v3 ad=1.76p pd=8.88u as=1.76p ps=8.88u w=4u l=0.28u
X806 a_41684_220611# ESD_RAIL ESD_RAIL VSS nfet_06v0 ad=13p pd=50.52u as=13p ps=50.52u w=50u l=0.7u
X807 ESD_RAIL ESD_RAIL a_41684_220611# VSS nfet_06v0 ad=13p pd=50.52u as=13p ps=50.52u w=50u l=0.7u
X808 a_44789_189064# a_43813_189064# ESD_RAIL ESD_RAIL pfet_06v0 ad=1.3p pd=5.52u as=1.3p ps=5.52u w=5u l=0.7u
X809 a_41684_232275# a_41684_220611# a_41684_220611# VSS nfet_06v0 ad=13p pd=50.52u as=13p ps=50.52u w=50u l=0.7u
X810 a_41684_220611# ESD_RAIL ESD_RAIL VSS nfet_06v0 ad=13p pd=50.52u as=13p ps=50.52u w=50u l=0.7u
D15 VSS PAD_P diode_nd2ps_06v0 pj=51.8u area=22.5p
X811 VDD FS_N_GATE FS_N_WELL FS_N_WELL pfet_03v3 ad=6.16p pd=28.88u as=6.16p ps=28.88u w=14u l=0.28u
X812 a_41684_220611# a_41684_220611# a_41684_232275# VSS nfet_06v0 ad=13p pd=50.52u as=13p ps=50.52u w=50u l=0.7u
X813 PULLUP_P_BLEED_6 PULLUP_P_GATE VSS ppolyf_u_1k r_width=1u r_length=12.5u
X814 a_41684_220611# ESD_RAIL ESD_RAIL VSS nfet_06v0 ad=13p pd=50.52u as=13p ps=50.52u w=50u l=0.7u
X815 VSS a_42245_162628# ESD_RAIL VSS nfet_06v0 ad=13p pd=50.52u as=13p ps=50.52u w=50u l=0.7u
X816 a_41684_220611# a_41684_220611# a_41684_232275# VSS nfet_06v0 ad=13p pd=50.52u as=13p ps=50.52u w=50u l=0.7u
X817 a_41684_232275# a_41684_220611# a_41684_220611# VSS nfet_06v0 ad=13p pd=50.52u as=13p ps=50.52u w=50u l=0.7u
X818 HS_P_0 HS_P PAD_P VSS nfet_06v0 ad=8.8p pd=40.88u as=8.8p ps=40.88u w=20u l=0.7u
X819 VDD FS_N_GATE FS_N_WELL FS_N_WELL pfet_03v3 ad=6.16p pd=28.88u as=6.16p ps=28.88u w=14u l=0.28u
X820 a_41684_220611# a_41684_220611# a_41684_232275# VSS nfet_06v0 ad=13p pd=50.52u as=13p ps=50.52u w=50u l=0.7u
X821 a_41684_232275# a_41684_220611# a_41684_220611# VSS nfet_06v0 ad=13p pd=50.52u as=13p ps=50.52u w=50u l=0.7u
X822 FS_P_OUT FS_P_GATE FS_P_WELL FS_P_WELL pfet_03v3 ad=6.16p pd=28.88u as=6.16p ps=28.88u w=14u l=0.28u
X823 a_41684_220611# ESD_RAIL ESD_RAIL VSS nfet_06v0 ad=13p pd=50.52u as=13p ps=50.52u w=50u l=0.7u
X824 PAD_P BYPASS_ENABLE RX_P VSS nfet_06v0 ad=8.8p pd=40.88u as=8.8p ps=40.88u w=20u l=0.7u
X825 VDD FS_N_GATE FS_N_WELL FS_N_WELL pfet_03v3 ad=6.16p pd=28.88u as=6.16p ps=28.88u w=14u l=0.28u
X826 a_41684_220611# a_41684_220611# a_41684_232275# VSS nfet_06v0 ad=13p pd=50.52u as=13p ps=50.52u w=50u l=0.7u
X827 a_41684_232275# a_41684_220611# a_41684_220611# VSS nfet_06v0 ad=13p pd=50.52u as=13p ps=50.52u w=50u l=0.7u
X828 a_41684_220611# a_41684_220611# a_41684_232275# VSS nfet_06v0 ad=13p pd=50.52u as=13p ps=50.52u w=50u l=0.7u
X829 FS_P_OUT FS_P_GATE FS_P_WELL FS_P_WELL pfet_03v3 ad=6.16p pd=28.88u as=6.16p ps=28.88u w=14u l=0.28u
X830 ESD_RAIL ESD_RAIL a_41684_220611# VSS nfet_06v0 ad=13p pd=50.52u as=13p ps=50.52u w=50u l=0.7u
X831 a_41684_232275# a_41684_232275# VSS VSS nfet_06v0 ad=13p pd=50.52u as=13p ps=50.52u w=50u l=0.7u
X832 VSS a_41684_232275# a_41684_232275# VSS nfet_06v0 ad=13p pd=50.52u as=13p ps=50.52u w=50u l=0.7u
X833 ESD_RAIL ESD_RAIL a_41684_220611# VSS nfet_06v0 ad=13p pd=50.52u as=13p ps=50.52u w=50u l=0.7u
X834 ESD_RAIL ESD_RAIL a_41684_220611# VSS nfet_06v0 ad=13p pd=50.52u as=13p ps=50.52u w=50u l=0.7u
X835 VDD PULLUP_P_GATE PULLUP_P_WELL PULLUP_P_WELL pfet_03v3 ad=8.8p pd=40.88u as=8.8p ps=40.88u w=20u l=0.28u
X836 PAD_P BYPASS_ENABLE RX_P VSS nfet_06v0 ad=8.8p pd=40.88u as=8.8p ps=40.88u w=20u l=0.7u
X837 VSS a_42245_162628# ESD_RAIL VSS nfet_06v0 ad=13p pd=50.52u as=13p ps=50.52u w=50u l=0.7u
X838 a_41684_232275# a_41684_232275# VSS VSS nfet_06v0 ad=13p pd=50.52u as=13p ps=50.52u w=50u l=0.7u
X839 ESD_RAIL ESD_RAIL a_41684_220611# VSS nfet_06v0 ad=13p pd=50.52u as=13p ps=50.52u w=50u l=0.7u
X840 VSS a_42245_162628# ESD_RAIL VSS nfet_06v0 ad=13p pd=50.52u as=13p ps=50.52u w=50u l=0.7u
X841 ESD_RAIL a_44789_189064# a_42245_162628# ESD_RAIL pfet_06v0 ad=1.3p pd=5.52u as=1.3p ps=5.52u w=5u l=0.7u
X842 VSS a_41684_232275# a_41684_232275# VSS nfet_06v0 ad=13p pd=50.52u as=13p ps=50.52u w=50u l=0.7u
X843 VDD FS_N_GATE FS_N_WELL FS_N_WELL pfet_03v3 ad=6.16p pd=28.88u as=6.16p ps=28.88u w=14u l=0.28u
X844 ESD_RAIL ESD_RAIL a_41684_220611# VSS nfet_06v0 ad=13p pd=50.52u as=13p ps=50.52u w=50u l=0.7u
X845 a_41684_220611# a_41684_220611# a_41684_232275# VSS nfet_06v0 ad=13p pd=50.52u as=13p ps=50.52u w=50u l=0.7u
D16 PAD_P ESD_RAIL diode_pd2nw_06v0 pj=51.8u area=22.5p
X846 HS_P_5 HS_PBIAS VDD VDD pfet_03v3 ad=8.8p pd=40.88u as=8.8p ps=40.88u w=20u l=1u
X847 a_41684_232275# a_41684_232275# VSS VSS nfet_06v0 ad=13p pd=50.52u as=13p ps=50.52u w=50u l=0.7u
X848 a_41684_232275# a_41684_232275# VSS VSS nfet_06v0 ad=13p pd=50.52u as=13p ps=50.52u w=50u l=0.7u
X849 VSS a_41684_232275# a_41684_232275# VSS nfet_06v0 ad=13p pd=50.52u as=13p ps=50.52u w=50u l=0.7u
X850 a_41684_232275# a_41684_232275# VSS VSS nfet_06v0 ad=13p pd=50.52u as=13p ps=50.52u w=50u l=0.7u
X851 a_41684_220611# a_41684_220611# a_41684_232275# VSS nfet_06v0 ad=13p pd=50.52u as=13p ps=50.52u w=50u l=0.7u
X852 a_41684_232275# a_41684_232275# VSS VSS nfet_06v0 ad=13p pd=50.52u as=13p ps=50.52u w=50u l=0.7u
X853 VSS a_41684_232275# a_41684_232275# VSS nfet_06v0 ad=13p pd=50.52u as=13p ps=50.52u w=50u l=0.7u
X854 VSS a_41684_232275# a_41684_232275# VSS nfet_06v0 ad=13p pd=50.52u as=13p ps=50.52u w=50u l=0.7u
X855 a_41684_232275# a_41684_232275# VSS VSS nfet_06v0 ad=13p pd=50.52u as=13p ps=50.52u w=50u l=0.7u
X856 ESD_RAIL a_42245_162628# VSS VSS nfet_06v0 ad=13p pd=50.52u as=13p ps=50.52u w=50u l=0.7u
X857 a_41684_232275# a_41684_220611# a_41684_220611# VSS nfet_06v0 ad=13p pd=50.52u as=13p ps=50.52u w=50u l=0.7u
X858 HS_P_8 HS_P PAD_P VSS nfet_06v0 ad=8.8p pd=40.88u as=8.8p ps=40.88u w=20u l=0.7u
X859 FS_P_OUT FS_P_GATE FS_P_WELL FS_P_WELL pfet_03v3 ad=6.16p pd=28.88u as=6.16p ps=28.88u w=14u l=0.28u
X860 VSS a_41684_232275# a_41684_232275# VSS nfet_06v0 ad=13p pd=50.52u as=13p ps=50.52u w=50u l=0.7u
X861 VSS a_41684_232275# a_41684_232275# VSS nfet_06v0 ad=13p pd=50.52u as=13p ps=50.52u w=50u l=0.7u
X862 a_41684_232275# a_41684_232275# VSS VSS nfet_06v0 ad=13p pd=50.52u as=13p ps=50.52u w=50u l=0.7u
X863 FS_P_OUT FS_P_GATE FS_P_WELL FS_P_WELL pfet_03v3 ad=6.16p pd=28.88u as=6.16p ps=28.88u w=14u l=0.28u
X864 a_41684_232275# a_41684_220611# a_41684_220611# VSS nfet_06v0 ad=13p pd=50.52u as=13p ps=50.52u w=50u l=0.7u
X865 VSS a_41684_232275# a_41684_232275# VSS nfet_06v0 ad=13p pd=50.52u as=13p ps=50.52u w=50u l=0.7u
X866 ESD_RAIL ESD_RAIL a_41684_220611# VSS nfet_06v0 ad=13p pd=50.52u as=13p ps=50.52u w=50u l=0.7u
X867 a_41684_232275# a_41684_232275# VSS VSS nfet_06v0 ad=13p pd=50.52u as=13p ps=50.52u w=50u l=0.7u
X868 VSS a_41684_232275# a_41684_232275# VSS nfet_06v0 ad=13p pd=50.52u as=13p ps=50.52u w=50u l=0.7u
X869 a_41684_232275# a_41684_232275# VSS VSS nfet_06v0 ad=13p pd=50.52u as=13p ps=50.52u w=50u l=0.7u
X870 VSS a_41684_232275# a_41684_232275# VSS nfet_06v0 ad=13p pd=50.52u as=13p ps=50.52u w=50u l=0.7u
X871 a_41684_232275# a_41684_232275# VSS VSS nfet_06v0 ad=13p pd=50.52u as=13p ps=50.52u w=50u l=0.7u
X872 ESD_RAIL a_42245_162628# VSS VSS nfet_06v0 ad=13p pd=50.52u as=13p ps=50.52u w=50u l=0.7u
X873 VSS a_41684_232275# a_41684_232275# VSS nfet_06v0 ad=13p pd=50.52u as=13p ps=50.52u w=50u l=0.7u
X874 a_41684_232275# a_41684_232275# VSS VSS nfet_06v0 ad=13p pd=50.52u as=13p ps=50.52u w=50u l=0.7u
X875 VSS a_41684_232275# a_41684_232275# VSS nfet_06v0 ad=13p pd=50.52u as=13p ps=50.52u w=50u l=0.7u
X876 DIV_LOW_N DIV_ENABLE VSS VSS nfet_03v3 ad=8.8p pd=40.88u as=8.8p ps=40.88u w=20u l=0.28u
X877 a_41005_203545# a_53878_203545# ESD_RAIL ppolyf_u r_width=0.8u r_length=63.855u
X878 VDD FS_N_GATE FS_N_WELL FS_N_WELL pfet_03v3 ad=6.16p pd=28.88u as=6.16p ps=28.88u w=14u l=0.28u
X879 a_41684_220611# a_41684_220611# a_41684_232275# VSS nfet_06v0 ad=13p pd=50.52u as=13p ps=50.52u w=50u l=0.7u
X880 a_41684_232275# a_41684_232275# VSS VSS nfet_06v0 ad=13p pd=50.52u as=13p ps=50.52u w=50u l=0.7u
X881 ESD_RAIL ESD_RAIL a_41684_220611# VSS nfet_06v0 ad=13p pd=50.52u as=13p ps=50.52u w=50u l=0.7u
X882 a_41684_232275# a_41684_232275# VSS VSS nfet_06v0 ad=13p pd=50.52u as=13p ps=50.52u w=50u l=0.7u
X883 a_41684_220611# ESD_RAIL ESD_RAIL VSS nfet_06v0 ad=13p pd=50.52u as=13p ps=50.52u w=50u l=0.7u
X884 ESD_RAIL a_42245_162628# VSS VSS nfet_06v0 ad=13p pd=50.52u as=13p ps=50.52u w=50u l=0.7u
X885 VSS a_43813_189064# a_44789_189064# VSS nfet_06v0 ad=1.3p pd=5.52u as=1.3p ps=5.52u w=5u l=0.7u
X886 VSS a_41684_232275# a_41684_232275# VSS nfet_06v0 ad=13p pd=50.52u as=13p ps=50.52u w=50u l=0.7u
X887 VSS a_41684_232275# a_41684_232275# VSS nfet_06v0 ad=13p pd=50.52u as=13p ps=50.52u w=50u l=0.7u
X888 a_41684_232275# a_41684_232275# VSS VSS nfet_06v0 ad=13p pd=50.52u as=13p ps=50.52u w=50u l=0.7u
X889 ESD_RAIL ESD_RAIL a_41684_220611# VSS nfet_06v0 ad=13p pd=50.52u as=13p ps=50.52u w=50u l=0.7u
X890 TERM_GATE_P_BLEED_0 TERM_GATE_P_BLEED_1 VSS ppolyf_u_1k r_width=1u r_length=12.5u
X891 HS_P_7 HS_P PAD_P VSS nfet_06v0 ad=8.8p pd=40.88u as=8.8p ps=40.88u w=20u l=0.7u
X892 a_41684_220611# ESD_RAIL ESD_RAIL VSS nfet_06v0 ad=13p pd=50.52u as=13p ps=50.52u w=50u l=0.7u
X893 a_41684_232275# a_41684_232275# VSS VSS nfet_06v0 ad=13p pd=50.52u as=13p ps=50.52u w=50u l=0.7u
X894 VSS a_41684_232275# a_41684_232275# VSS nfet_06v0 ad=13p pd=50.52u as=13p ps=50.52u w=50u l=0.7u
X895 a_41684_232275# a_41684_232275# VSS VSS nfet_06v0 ad=13p pd=50.52u as=13p ps=50.52u w=50u l=0.7u
X896 VSS a_42245_162628# ESD_RAIL VSS nfet_06v0 ad=13p pd=50.52u as=13p ps=50.52u w=50u l=0.7u
X897 VSS a_41684_232275# a_41684_232275# VSS nfet_06v0 ad=13p pd=50.52u as=13p ps=50.52u w=50u l=0.7u
X898 a_41684_232275# a_41684_220611# a_41684_220611# VSS nfet_06v0 ad=13p pd=50.52u as=13p ps=50.52u w=50u l=0.7u
X899 a_41684_220611# ESD_RAIL ESD_RAIL VSS nfet_06v0 ad=13p pd=50.52u as=13p ps=50.52u w=50u l=0.7u
X900 VSS a_41684_232275# a_41684_232275# VSS nfet_06v0 ad=13p pd=50.52u as=13p ps=50.52u w=50u l=0.7u
X901 ESD_RAIL ESD_RAIL a_41684_220611# VSS nfet_06v0 ad=13p pd=50.52u as=13p ps=50.52u w=50u l=0.7u
X902 VSS a_42245_162628# ESD_RAIL VSS nfet_06v0 ad=13p pd=50.52u as=13p ps=50.52u w=50u l=0.7u
X903 a_41684_232275# a_41684_232275# VSS VSS nfet_06v0 ad=13p pd=50.52u as=13p ps=50.52u w=50u l=0.7u
X904 a_41684_232275# a_41684_232275# VSS VSS nfet_06v0 ad=13p pd=50.52u as=13p ps=50.52u w=50u l=0.7u
X905 FS_P_BLEED_5 FS_P_BLEED_6 VSS ppolyf_u_1k r_width=1u r_length=12.5u
X906 VSS a_44789_189064# a_42245_162628# VSS nfet_06v0 ad=1.3p pd=5.52u as=1.3p ps=5.52u w=5u l=0.7u
X907 VDD FS_P_GATE FS_P_WELL FS_P_WELL pfet_03v3 ad=6.16p pd=28.88u as=6.16p ps=28.88u w=14u l=0.28u
X908 PULLUP_P_OUT PULLUP_P_GATE PULLUP_P_WELL PULLUP_P_WELL pfet_03v3 ad=8.8p pd=40.88u as=8.8p ps=40.88u w=20u l=0.28u
X909 VSS a_41684_232275# a_41684_232275# VSS nfet_06v0 ad=13p pd=50.52u as=13p ps=50.52u w=50u l=0.7u
X910 a_41684_220611# ESD_RAIL ESD_RAIL VSS nfet_06v0 ad=13p pd=50.52u as=13p ps=50.52u w=50u l=0.7u
X911 VSS a_41684_232275# a_41684_232275# VSS nfet_06v0 ad=13p pd=50.52u as=13p ps=50.52u w=50u l=0.7u
X912 ESD_RAIL ESD_RAIL a_41684_220611# VSS nfet_06v0 ad=13p pd=50.52u as=13p ps=50.52u w=50u l=0.7u
X913 DIV_P DIV_LOW_P VSS ppolyf_u_1k r_width=1u r_length=2u
X914 VSS a_44789_189064# a_42245_162628# VSS nfet_06v0 ad=1.3p pd=5.52u as=1.3p ps=5.52u w=5u l=0.7u
X915 a_41684_232275# a_41684_232275# VSS VSS nfet_06v0 ad=13p pd=50.52u as=13p ps=50.52u w=50u l=0.7u
X916 TERM_N_R TERM_GATE_N TERM_VCM VSS nfet_03v3 ad=8.8p pd=40.88u as=8.8p ps=40.88u w=20u l=0.28u
X917 a_41684_232275# a_41684_232275# VSS VSS nfet_06v0 ad=13p pd=50.52u as=13p ps=50.52u w=50u l=0.7u
X918 a_41684_220611# ESD_RAIL ESD_RAIL VSS nfet_06v0 ad=13p pd=50.52u as=13p ps=50.52u w=50u l=0.7u
X919 HS_P_1 HS_P PAD_P VSS nfet_06v0 ad=8.8p pd=40.88u as=8.8p ps=40.88u w=20u l=0.7u
X920 ESD_RAIL a_44789_189064# a_42245_162628# ESD_RAIL pfet_06v0 ad=1.3p pd=5.52u as=1.3p ps=5.52u w=5u l=0.7u
X921 ESD_RAIL ESD_RAIL a_41684_220611# VSS nfet_06v0 ad=13p pd=50.52u as=13p ps=50.52u w=50u l=0.7u
X922 ESD_RAIL ESD_RAIL a_41684_220611# VSS nfet_06v0 ad=13p pd=50.52u as=13p ps=50.52u w=50u l=0.7u
X923 TERM_P_R TERM_GATE_P TERM_VCM VSS nfet_03v3 ad=8.8p pd=40.88u as=8.8p ps=40.88u w=20u l=0.28u
X924 VSS a_41684_232275# a_41684_232275# VSS nfet_06v0 ad=13p pd=50.52u as=13p ps=50.52u w=50u l=0.7u
X925 VSS a_41684_232275# a_41684_232275# VSS nfet_06v0 ad=13p pd=50.52u as=13p ps=50.52u w=50u l=0.7u
X926 a_41684_220611# ESD_RAIL ESD_RAIL VSS nfet_06v0 ad=13p pd=50.52u as=13p ps=50.52u w=50u l=0.7u
X927 HS_N_5 HS_PBIAS VDD VDD pfet_03v3 ad=8.8p pd=40.88u as=8.8p ps=40.88u w=20u l=1u
X928 PAD_P TERM_P_R VSS ppolyf_u r_width=16u r_length=1.3u
X929 VSS a_42245_162628# ESD_RAIL VSS nfet_06v0 ad=13p pd=50.52u as=13p ps=50.52u w=50u l=0.7u
X930 a_41684_232275# a_41684_232275# VSS VSS nfet_06v0 ad=13p pd=50.52u as=13p ps=50.52u w=50u l=0.7u
X931 VSS a_41684_232275# a_41684_232275# VSS nfet_06v0 ad=13p pd=50.52u as=13p ps=50.52u w=50u l=0.7u
X932 TERM_N_R TERM_GATE_N TERM_VCM VSS nfet_03v3 ad=8.8p pd=40.88u as=8.8p ps=40.88u w=20u l=0.28u
X933 ESD_RAIL ESD_RAIL a_41684_220611# VSS nfet_06v0 ad=13p pd=50.52u as=13p ps=50.52u w=50u l=0.7u
X934 HS_P_4 HS_P PAD_P VSS nfet_06v0 ad=8.8p pd=40.88u as=8.8p ps=40.88u w=20u l=0.7u
X935 a_41005_204385# a_53878_204665# ESD_RAIL ppolyf_u r_width=0.8u r_length=63.855u
X936 VSS a_41684_232275# a_41684_232275# VSS nfet_06v0 ad=13p pd=50.52u as=13p ps=50.52u w=50u l=0.7u
X937 a_41684_232275# a_41684_232275# VSS VSS nfet_06v0 ad=13p pd=50.52u as=13p ps=50.52u w=50u l=0.7u
X938 a_41684_220611# ESD_RAIL ESD_RAIL VSS nfet_06v0 ad=13p pd=50.52u as=13p ps=50.52u w=50u l=0.7u
X939 VSS a_41684_232275# a_41684_232275# VSS nfet_06v0 ad=13p pd=50.52u as=13p ps=50.52u w=50u l=0.7u
X940 a_41684_232275# a_41684_220611# a_41684_220611# VSS nfet_06v0 ad=13p pd=50.52u as=13p ps=50.52u w=50u l=0.7u
X941 FS_P_GATE VDD FS_P_WELL FS_P_WELL pfet_03v3 ad=1.76p pd=8.88u as=1.76p ps=8.88u w=4u l=0.28u
X942 FS_N_BLEED_2 FS_N_BLEED_3 VSS ppolyf_u_1k r_width=1u r_length=12.5u
X943 a_41684_232275# a_41684_232275# VSS VSS nfet_06v0 ad=13p pd=50.52u as=13p ps=50.52u w=50u l=0.7u
X944 ESD_RAIL ESD_RAIL a_41684_220611# VSS nfet_06v0 ad=13p pd=50.52u as=13p ps=50.52u w=50u l=0.7u
D17 PAD_N ESD_RAIL diode_pd2nw_06v0 pj=51.8u area=22.5p
X945 a_41684_220611# ESD_RAIL ESD_RAIL VSS nfet_06v0 ad=13p pd=50.52u as=13p ps=50.52u w=50u l=0.7u
X946 ESD_RAIL a_42245_162628# VSS VSS nfet_06v0 ad=13p pd=50.52u as=13p ps=50.52u w=50u l=0.7u
X947 a_44789_189064# a_43813_189064# VSS VSS nfet_06v0 ad=1.3p pd=5.52u as=1.3p ps=5.52u w=5u l=0.7u
X948 FS_N_GATE FS_HIGH_N FS_N_WELL FS_N_WELL pfet_03v3 ad=1.76p pd=8.88u as=1.76p ps=8.88u w=4u l=0.28u
X949 a_41684_232275# a_41684_220611# a_41684_220611# VSS nfet_06v0 ad=13p pd=50.52u as=13p ps=50.52u w=50u l=0.7u
X950 a_41684_220611# a_41684_220611# a_41684_232275# VSS nfet_06v0 ad=13p pd=50.52u as=13p ps=50.52u w=50u l=0.7u
X951 DIV_N DIV_LOW_N VSS ppolyf_u_1k r_width=1u r_length=2u
D18 PAD_P ESD_RAIL diode_pd2nw_06v0 pj=51.8u area=22.5p
X952 ESD_RAIL a_42245_162628# VSS VSS nfet_06v0 ad=13p pd=50.52u as=13p ps=50.52u w=50u l=0.7u
X953 TERM_GATE_N TERM_GATE_N_BLEED_0 VSS ppolyf_u_1k r_width=1u r_length=12.5u
X954 ESD_RAIL ESD_RAIL a_41684_220611# VSS nfet_06v0 ad=13p pd=50.52u as=13p ps=50.52u w=50u l=0.7u
X955 PULLUP_N_WELL PULLUP_N_BLEED_0 VSS ppolyf_u_1k r_width=1u r_length=12.5u
X956 a_41684_232275# a_41684_220611# a_41684_220611# VSS nfet_06v0 ad=13p pd=50.52u as=13p ps=50.52u w=50u l=0.7u
X957 FS_P_BLEED_3 FS_P_BLEED_4 VSS ppolyf_u_1k r_width=1u r_length=12.5u
X958 a_41684_232275# a_41684_220611# a_41684_220611# VSS nfet_06v0 ad=13p pd=50.52u as=13p ps=50.52u w=50u l=0.7u
X959 a_41684_220611# ESD_RAIL ESD_RAIL VSS nfet_06v0 ad=13p pd=50.52u as=13p ps=50.52u w=50u l=0.7u
X960 ESD_RAIL ESD_RAIL a_41684_220611# VSS nfet_06v0 ad=13p pd=50.52u as=13p ps=50.52u w=50u l=0.7u
X961 VDD FS_P_GATE FS_P_WELL FS_P_WELL pfet_03v3 ad=6.16p pd=28.88u as=6.16p ps=28.88u w=14u l=0.28u
X962 PULLUP_P_OUT PULLUP_P_GATE PULLUP_P_WELL PULLUP_P_WELL pfet_03v3 ad=8.8p pd=40.88u as=8.8p ps=40.88u w=20u l=0.28u
X963 PULLUP_P_BLEED_2 PULLUP_P_BLEED_3 VSS ppolyf_u_1k r_width=1u r_length=12.5u
X964 FS_N_BLEED_4 FS_N_BLEED_5 VSS ppolyf_u_1k r_width=1u r_length=12.5u
X965 a_41684_232275# a_41684_220611# a_41684_220611# VSS nfet_06v0 ad=13p pd=50.52u as=13p ps=50.52u w=50u l=0.7u
X966 a_41684_220611# ESD_RAIL ESD_RAIL VSS nfet_06v0 ad=13p pd=50.52u as=13p ps=50.52u w=50u l=0.7u
X967 a_41684_220611# ESD_RAIL ESD_RAIL VSS nfet_06v0 ad=13p pd=50.52u as=13p ps=50.52u w=50u l=0.7u
X968 a_41684_232275# a_41684_220611# a_41684_220611# VSS nfet_06v0 ad=13p pd=50.52u as=13p ps=50.52u w=50u l=0.7u
X969 ESD_RAIL ESD_RAIL a_41684_220611# VSS nfet_06v0 ad=13p pd=50.52u as=13p ps=50.52u w=50u l=0.7u
X970 HS_P_13 HS_P PAD_P VSS nfet_06v0 ad=8.8p pd=40.88u as=8.8p ps=40.88u w=20u l=0.7u
X971 a_41684_220611# a_41684_220611# a_41684_232275# VSS nfet_06v0 ad=13p pd=50.52u as=13p ps=50.52u w=50u l=0.7u
X972 a_41684_220611# a_41684_220611# a_41684_232275# VSS nfet_06v0 ad=13p pd=50.52u as=13p ps=50.52u w=50u l=0.7u
X973 a_41684_220611# ESD_RAIL ESD_RAIL VSS nfet_06v0 ad=13p pd=50.52u as=13p ps=50.52u w=50u l=0.7u
X974 VDD PULLUP_N_GATE PULLUP_N_WELL PULLUP_N_WELL pfet_03v3 ad=8.8p pd=40.88u as=8.8p ps=40.88u w=20u l=0.28u
X975 HS_N_3 HS_PBIAS VDD VDD pfet_03v3 ad=8.8p pd=40.88u as=8.8p ps=40.88u w=20u l=1u
X976 a_41684_232275# a_41684_220611# a_41684_220611# VSS nfet_06v0 ad=13p pd=50.52u as=13p ps=50.52u w=50u l=0.7u
X977 a_41684_232275# a_41684_220611# a_41684_220611# VSS nfet_06v0 ad=13p pd=50.52u as=13p ps=50.52u w=50u l=0.7u
X978 ESD_RAIL ESD_RAIL a_41684_220611# VSS nfet_06v0 ad=13p pd=50.52u as=13p ps=50.52u w=50u l=0.7u
X979 a_41684_220611# a_41684_220611# a_41684_232275# VSS nfet_06v0 ad=13p pd=50.52u as=13p ps=50.52u w=50u l=0.7u
X980 a_41684_220611# a_41684_220611# a_41684_232275# VSS nfet_06v0 ad=13p pd=50.52u as=13p ps=50.52u w=50u l=0.7u
X981 ESD_RAIL ESD_RAIL a_41684_220611# VSS nfet_06v0 ad=13p pd=50.52u as=13p ps=50.52u w=50u l=0.7u
X982 a_41684_220611# ESD_RAIL ESD_RAIL VSS nfet_06v0 ad=13p pd=50.52u as=13p ps=50.52u w=50u l=0.7u
X983 VDD FS_P_GATE FS_P_WELL FS_P_WELL pfet_03v3 ad=6.16p pd=28.88u as=6.16p ps=28.88u w=14u l=0.28u
X984 a_41684_220611# ESD_RAIL ESD_RAIL VSS nfet_06v0 ad=13p pd=50.52u as=13p ps=50.52u w=50u l=0.7u
X985 ESD_RAIL ESD_RAIL a_41684_220611# VSS nfet_06v0 ad=13p pd=50.52u as=13p ps=50.52u w=50u l=0.7u
X986 a_41684_232275# a_41684_220611# a_41684_220611# VSS nfet_06v0 ad=13p pd=50.52u as=13p ps=50.52u w=50u l=0.7u
X987 a_41684_220611# a_41684_220611# a_41684_232275# VSS nfet_06v0 ad=13p pd=50.52u as=13p ps=50.52u w=50u l=0.7u
X988 a_41684_232275# a_41684_220611# a_41684_220611# VSS nfet_06v0 ad=13p pd=50.52u as=13p ps=50.52u w=50u l=0.7u
X989 a_41005_205505# a_53878_205785# ESD_RAIL ppolyf_u r_width=0.8u r_length=63.855u
X990 a_41684_232275# a_41684_220611# a_41684_220611# VSS nfet_06v0 ad=13p pd=50.52u as=13p ps=50.52u w=50u l=0.7u
X991 a_41684_220611# a_41684_220611# a_41684_232275# VSS nfet_06v0 ad=13p pd=50.52u as=13p ps=50.52u w=50u l=0.7u
X992 ESD_RAIL ESD_RAIL a_41684_220611# VSS nfet_06v0 ad=13p pd=50.52u as=13p ps=50.52u w=50u l=0.7u
X993 VSS a_41684_232275# a_41684_232275# VSS nfet_06v0 ad=13p pd=50.52u as=13p ps=50.52u w=50u l=0.7u
X994 a_41684_220611# ESD_RAIL ESD_RAIL VSS nfet_06v0 ad=13p pd=50.52u as=13p ps=50.52u w=50u l=0.7u
X995 ESD_RAIL ESD_RAIL a_41684_220611# VSS nfet_06v0 ad=13p pd=50.52u as=13p ps=50.52u w=50u l=0.7u
X996 VDD FS_P_GATE FS_P_WELL FS_P_WELL pfet_03v3 ad=6.16p pd=28.88u as=6.16p ps=28.88u w=14u l=0.28u
X997 a_41684_220611# a_41684_220611# a_41684_232275# VSS nfet_06v0 ad=13p pd=50.52u as=13p ps=50.52u w=50u l=0.7u
X998 a_41684_232275# a_41684_220611# a_41684_220611# VSS nfet_06v0 ad=22p pd=0.10088m as=13p ps=50.52u w=50u l=0.7u
X999 ESD_RAIL a_42245_162628# VSS VSS nfet_06v0 ad=13p pd=50.52u as=13p ps=50.52u w=50u l=0.7u
X1000 a_41684_232275# a_41684_220611# a_41684_220611# VSS nfet_06v0 ad=13p pd=50.52u as=13p ps=50.52u w=50u l=0.7u
X1001 HS_N_12 HS_N PAD_N VSS nfet_06v0 ad=8.8p pd=40.88u as=8.8p ps=40.88u w=20u l=0.7u
X1002 a_41684_232275# a_41684_220611# a_41684_220611# VSS nfet_06v0 ad=13p pd=50.52u as=13p ps=50.52u w=50u l=0.7u
X1003 VSS a_42245_162628# ESD_RAIL VSS nfet_06v0 ad=13p pd=50.52u as=13p ps=50.52u w=50u l=0.7u
X1004 VSS a_41684_232275# a_41684_232275# VSS nfet_06v0 ad=13p pd=50.52u as=13p ps=50.52u w=50u l=0.7u
X1005 a_41684_220611# a_41684_220611# a_41684_232275# VSS nfet_06v0 ad=13p pd=50.52u as=13p ps=50.52u w=50u l=0.7u
X1006 a_41684_232275# a_41684_220611# a_41684_220611# VSS nfet_06v0 ad=13p pd=50.52u as=13p ps=50.52u w=50u l=0.7u
X1007 a_41684_220611# a_41684_220611# a_41684_232275# VSS nfet_06v0 ad=13p pd=50.52u as=13p ps=50.52u w=50u l=0.7u
X1008 PAD_N BYPASS_ENABLE RX_N VSS nfet_06v0 ad=8.8p pd=40.88u as=8.8p ps=40.88u w=20u l=0.7u
X1009 a_41684_232275# a_41684_220611# a_41684_220611# VSS nfet_06v0 ad=13p pd=50.52u as=13p ps=50.52u w=50u l=0.7u
X1010 VSS a_42245_162628# ESD_RAIL VSS nfet_06v0 ad=13p pd=50.52u as=13p ps=50.52u w=50u l=0.7u
X1011 FS_N_OUT FS_N_GATE FS_N_WELL FS_N_WELL pfet_03v3 ad=6.16p pd=28.88u as=6.16p ps=28.88u w=14u l=0.28u
X1012 a_41684_220611# a_41684_220611# a_41684_232275# VSS nfet_06v0 ad=13p pd=50.52u as=13p ps=50.52u w=50u l=0.7u
X1013 a_41684_232275# a_41684_220611# a_41684_220611# VSS nfet_06v0 ad=13p pd=50.52u as=13p ps=50.52u w=50u l=0.7u
X1014 a_41684_232275# a_41684_232275# VSS VSS nfet_06v0 ad=13p pd=50.52u as=13p ps=50.52u w=50u l=0.7u
X1015 a_41684_220611# a_41684_220611# a_41684_232275# VSS nfet_06v0 ad=13p pd=50.52u as=13p ps=50.52u w=50u l=0.7u
X1016 ESD_RAIL ESD_RAIL a_41684_220611# VSS nfet_06v0 ad=13p pd=50.52u as=13p ps=50.52u w=50u l=0.7u
X1017 a_41684_232275# a_41684_220611# a_41684_220611# VSS nfet_06v0 ad=13p pd=50.52u as=13p ps=50.52u w=50u l=0.7u
X1018 FS_N_OUT FS_N_GATE FS_N_WELL FS_N_WELL pfet_03v3 ad=6.16p pd=28.88u as=6.16p ps=28.88u w=14u l=0.28u
X1019 a_41684_220611# a_41684_220611# a_41684_232275# VSS nfet_06v0 ad=13p pd=50.52u as=13p ps=50.52u w=50u l=0.7u
X1020 ESD_RAIL ESD_RAIL a_41684_220611# VSS nfet_06v0 ad=13p pd=50.52u as=13p ps=50.52u w=50u l=0.7u
X1021 a_41684_232275# a_41684_232275# VSS VSS nfet_06v0 ad=13p pd=50.52u as=13p ps=50.52u w=50u l=0.7u
X1022 HS_P_9 HS_P PAD_P VSS nfet_06v0 ad=8.8p pd=40.88u as=8.8p ps=40.88u w=20u l=0.7u
X1023 VDD PULLUP_N_GATE PULLUP_N_WELL PULLUP_N_WELL pfet_03v3 ad=8.8p pd=40.88u as=8.8p ps=40.88u w=20u l=0.28u
X1024 FS_N_OUT FS_N_GATE FS_N_WELL FS_N_WELL pfet_03v3 ad=6.16p pd=28.88u as=6.16p ps=28.88u w=14u l=0.28u
X1025 a_41684_232275# a_41684_220611# a_41684_220611# VSS nfet_06v0 ad=13p pd=50.52u as=13p ps=50.52u w=50u l=0.7u
X1026 VDD FS_P_GATE FS_P_WELL FS_P_WELL pfet_03v3 ad=6.16p pd=28.88u as=6.16p ps=28.88u w=14u l=0.28u
X1027 a_41684_220611# a_41684_220611# a_41684_232275# VSS nfet_06v0 ad=13p pd=50.52u as=13p ps=50.52u w=50u l=0.7u
X1028 a_41684_232275# a_41684_232275# VSS VSS nfet_06v0 ad=13p pd=50.52u as=13p ps=50.52u w=50u l=0.7u
X1029 a_41684_220611# a_41684_220611# a_41684_232275# VSS nfet_06v0 ad=13p pd=50.52u as=13p ps=50.52u w=50u l=0.7u
D19 PAD_N ESD_RAIL diode_pd2nw_06v0 pj=51.8u area=22.5p
X1030 FS_N_OUT FS_N_GATE FS_N_WELL FS_N_WELL pfet_03v3 ad=6.16p pd=28.88u as=6.16p ps=28.88u w=14u l=0.28u
X1031 a_41684_220611# ESD_RAIL ESD_RAIL VSS nfet_06v0 ad=13p pd=50.52u as=13p ps=50.52u w=50u l=0.7u
X1032 a_41684_232275# a_41684_220611# a_41684_220611# VSS nfet_06v0 ad=13p pd=50.52u as=13p ps=50.52u w=50u l=0.7u
X1033 a_41684_220611# a_41684_220611# a_41684_232275# VSS nfet_06v0 ad=13p pd=50.52u as=13p ps=50.52u w=50u l=0.7u
X1034 HS_P_2 HS_PBIAS VDD VDD pfet_03v3 ad=8.8p pd=40.88u as=8.8p ps=40.88u w=20u l=1u
X1035 a_41684_220611# a_41684_220611# a_41684_232275# VSS nfet_06v0 ad=13p pd=50.52u as=13p ps=50.52u w=50u l=0.7u
X1036 a_41684_232275# a_41684_220611# a_41684_220611# VSS nfet_06v0 ad=13p pd=50.52u as=13p ps=50.52u w=50u l=0.7u
X1037 VSS a_41684_232275# a_41684_232275# VSS nfet_06v0 ad=13p pd=50.52u as=13p ps=50.52u w=50u l=0.7u
X1038 a_41684_220611# ESD_RAIL ESD_RAIL VSS nfet_06v0 ad=13p pd=50.52u as=13p ps=50.52u w=50u l=0.7u
X1039 a_41684_220611# a_41684_220611# a_41684_232275# VSS nfet_06v0 ad=13p pd=50.52u as=13p ps=50.52u w=50u l=0.7u
X1040 HS_P_8 HS_PBIAS VDD VDD pfet_03v3 ad=8.8p pd=40.88u as=8.8p ps=40.88u w=20u l=1u
X1041 a_41684_232275# a_41684_220611# a_41684_220611# VSS nfet_06v0 ad=13p pd=50.52u as=13p ps=50.52u w=50u l=0.7u
X1042 ESD_RAIL a_42245_162628# VSS VSS nfet_06v0 ad=13p pd=50.52u as=13p ps=50.52u w=50u l=0.7u
X1043 VSS a_41684_232275# a_41684_232275# VSS nfet_06v0 ad=13p pd=50.52u as=13p ps=50.52u w=50u l=0.7u
X1044 VSS a_41684_232275# a_41684_232275# VSS nfet_06v0 ad=13p pd=50.52u as=13p ps=50.52u w=50u l=0.7u
X1045 VDD FS_P_GATE FS_P_WELL FS_P_WELL pfet_03v3 ad=6.16p pd=28.88u as=6.16p ps=28.88u w=14u l=0.28u
X1046 a_41684_220611# a_41684_220611# a_41684_232275# VSS nfet_06v0 ad=13p pd=50.52u as=13p ps=50.52u w=50u l=0.7u
X1047 a_41684_232275# a_41684_220611# a_41684_220611# VSS nfet_06v0 ad=13p pd=50.52u as=13p ps=50.52u w=50u l=0.7u
X1048 ESD_RAIL a_42245_162628# VSS VSS nfet_06v0 ad=13p pd=50.52u as=13p ps=50.52u w=50u l=0.7u
X1049 ESD_RAIL a_42245_162628# VSS VSS nfet_06v0 ad=13p pd=50.52u as=13p ps=50.52u w=50u l=0.7u
X1050 a_41684_232275# a_41684_220611# a_41684_220611# VSS nfet_06v0 ad=13p pd=50.52u as=13p ps=50.52u w=50u l=0.7u
X1051 VDD FS_P_GATE FS_P_WELL FS_P_WELL pfet_03v3 ad=6.16p pd=28.88u as=6.16p ps=28.88u w=14u l=0.28u
X1052 ESD_RAIL a_44789_189064# a_42245_162628# ESD_RAIL pfet_06v0 ad=1.3p pd=5.52u as=1.3p ps=5.52u w=5u l=0.7u
X1053 FS_N_OUT FS_N_GATE FS_N_WELL FS_N_WELL pfet_03v3 ad=6.16p pd=28.88u as=6.16p ps=28.88u w=14u l=0.28u
X1054 HS_N_13 HS_PBIAS VDD VDD pfet_03v3 ad=8.8p pd=40.88u as=8.8p ps=40.88u w=20u l=1u
X1055 ESD_RAIL ESD_RAIL a_41684_220611# VSS nfet_06v0 ad=13p pd=50.52u as=13p ps=50.52u w=50u l=0.7u
X1056 VDD FS_P_GATE FS_P_WELL FS_P_WELL pfet_03v3 ad=6.16p pd=28.88u as=6.16p ps=28.88u w=14u l=0.28u
X1057 a_41684_220611# a_41684_220611# a_41684_232275# VSS nfet_06v0 ad=13p pd=50.52u as=13p ps=50.52u w=50u l=0.7u
X1058 a_41684_232275# a_41684_220611# a_41684_220611# VSS nfet_06v0 ad=13p pd=50.52u as=13p ps=50.52u w=50u l=0.7u
X1059 PAD_P DIV_P VSS ppolyf_u_1k r_width=1u r_length=2u
X1060 PULLDOWN_N_R PULLDOWN_N VSS VSS nfet_03v3 ad=3.52p pd=16.88u as=3.52p ps=16.88u w=8u l=0.28u
X1061 a_41684_232275# a_41684_220611# a_41684_220611# VSS nfet_06v0 ad=13p pd=50.52u as=13p ps=50.52u w=50u l=0.7u
X1062 FS_P_OUT PAD_P VSS ppolyf_s r_width=2u r_length=3.5u
X1063 FS_N_OUT FS_N_GATE FS_N_WELL FS_N_WELL pfet_03v3 ad=6.16p pd=28.88u as=6.16p ps=28.88u w=14u l=0.28u
X1064 a_41684_232275# a_41684_232275# VSS VSS nfet_06v0 ad=13p pd=50.52u as=13p ps=50.52u w=50u l=0.7u
X1065 VDD FS_P_GATE FS_P_WELL FS_P_WELL pfet_03v3 ad=6.16p pd=28.88u as=6.16p ps=28.88u w=14u l=0.28u
X1066 a_41684_232275# a_41684_232275# VSS VSS nfet_06v0 ad=13p pd=50.52u as=13p ps=50.52u w=50u l=0.7u
X1067 a_41684_232275# a_41684_220611# a_41684_220611# VSS nfet_06v0 ad=13p pd=50.52u as=13p ps=50.52u w=50u l=0.7u
X1068 HS_P_0 HS_PBIAS VDD VDD pfet_03v3 ad=8.8p pd=40.88u as=8.8p ps=40.88u w=20u l=1u
X1069 a_41005_205505# a_53878_205225# ESD_RAIL ppolyf_u r_width=0.8u r_length=63.855u
X1070 a_41684_232275# a_41684_232275# VSS VSS nfet_06v0 ad=13p pd=50.52u as=13p ps=50.52u w=50u l=0.7u
X1071 a_41684_232275# a_41684_232275# VSS VSS nfet_06v0 ad=13p pd=50.52u as=13p ps=50.52u w=50u l=0.7u
X1072 TERM_GATE_N_BLEED_2 VSS VSS ppolyf_u_1k r_width=1u r_length=12.5u
X1073 a_41684_220611# ESD_RAIL ESD_RAIL VSS nfet_06v0 ad=13p pd=50.52u as=13p ps=50.52u w=50u l=0.7u
X1074 a_44789_189064# a_43813_189064# VSS VSS nfet_06v0 ad=1.3p pd=5.52u as=1.3p ps=5.52u w=5u l=0.7u
X1075 VDD FS_P_GATE FS_P_WELL FS_P_WELL pfet_03v3 ad=6.16p pd=28.88u as=6.16p ps=28.88u w=14u l=0.28u
X1076 PULLUP_P_OUT PULLUP_P_GATE PULLUP_P_WELL PULLUP_P_WELL pfet_03v3 ad=8.8p pd=40.88u as=8.8p ps=40.88u w=20u l=0.28u
X1077 a_41684_232275# a_41684_220611# a_41684_220611# VSS nfet_06v0 ad=13p pd=50.52u as=13p ps=50.52u w=50u l=0.7u
X1078 TERM_P_R TERM_GATE_P TERM_VCM VSS nfet_03v3 ad=8.8p pd=40.88u as=8.8p ps=40.88u w=20u l=0.28u
X1079 VSS a_41684_232275# a_41684_232275# VSS nfet_06v0 ad=13p pd=50.52u as=13p ps=50.52u w=50u l=0.7u
X1080 FS_N_OUT FS_N_GATE FS_N_WELL FS_N_WELL pfet_03v3 ad=6.16p pd=28.88u as=6.16p ps=28.88u w=14u l=0.28u
X1081 VSS a_41684_232275# a_41684_232275# VSS nfet_06v0 ad=13p pd=50.52u as=13p ps=50.52u w=50u l=0.7u
X1082 TERM_OR_N_B FS_LOW_N TERM_OR_N_NS VSS nfet_03v3 ad=0.88p pd=4.88u as=0.88p ps=4.88u w=2u l=0.28u
X1083 PULLUP_P_BLEED_5 PULLUP_P_BLEED_6 VSS ppolyf_u_1k r_width=1u r_length=12.5u
X1084 a_41684_232275# a_41684_232275# VSS VSS nfet_06v0 ad=13p pd=50.52u as=13p ps=50.52u w=50u l=0.7u
X1085 HS_P_2 HS_P PAD_P VSS nfet_06v0 ad=8.8p pd=40.88u as=8.8p ps=40.88u w=20u l=0.7u
X1086 VSS a_41684_232275# a_41684_232275# VSS nfet_06v0 ad=13p pd=50.52u as=13p ps=50.52u w=50u l=0.7u
X1087 VDD FS_P_GATE FS_P_WELL FS_P_WELL pfet_03v3 ad=6.16p pd=28.88u as=6.16p ps=28.88u w=14u l=0.28u
X1088 VSS a_41684_232275# a_41684_232275# VSS nfet_06v0 ad=13p pd=50.52u as=13p ps=50.52u w=50u l=0.7u
X1089 a_41684_232275# a_41684_232275# VSS VSS nfet_06v0 ad=13p pd=50.52u as=13p ps=50.52u w=50u l=0.7u
X1090 VSS a_41684_232275# a_41684_232275# VSS nfet_06v0 ad=13p pd=50.52u as=13p ps=50.52u w=50u l=0.7u
X1091 HS_N_7 HS_PBIAS VDD VDD pfet_03v3 ad=8.8p pd=40.88u as=8.8p ps=40.88u w=20u l=1u
X1092 FS_N_OUT FS_N_GATE FS_N_WELL FS_N_WELL pfet_03v3 ad=6.16p pd=28.88u as=6.16p ps=28.88u w=14u l=0.28u
X1093 VDD FS_P_GATE FS_P_WELL FS_P_WELL pfet_03v3 ad=6.16p pd=28.88u as=6.16p ps=28.88u w=14u l=0.28u
X1094 VSS a_42245_162628# ESD_RAIL VSS nfet_06v0 ad=13p pd=50.52u as=13p ps=50.52u w=50u l=0.7u
X1095 VSS a_41684_232275# a_41684_232275# VSS nfet_06v0 ad=13p pd=50.52u as=13p ps=50.52u w=50u l=0.7u
X1096 a_41684_220611# a_41684_220611# a_41684_232275# VSS nfet_06v0 ad=13p pd=50.52u as=13p ps=50.52u w=50u l=0.7u
X1097 VSS a_42245_162628# ESD_RAIL VSS nfet_06v0 ad=13p pd=50.52u as=13p ps=50.52u w=50u l=0.7u
X1098 VSS a_41684_232275# a_41684_232275# VSS nfet_06v0 ad=13p pd=50.52u as=13p ps=50.52u w=50u l=0.7u
X1099 a_41684_232275# a_41684_232275# VSS VSS nfet_06v0 ad=13p pd=50.52u as=13p ps=50.52u w=50u l=0.7u
X1100 a_41684_232275# a_41684_220611# a_41684_220611# VSS nfet_06v0 ad=13p pd=50.52u as=13p ps=50.52u w=50u l=0.7u
X1101 VSS a_42245_162628# ESD_RAIL VSS nfet_06v0 ad=13p pd=50.52u as=13p ps=50.52u w=50u l=0.7u
X1102 a_41684_232275# a_41684_232275# VSS VSS nfet_06v0 ad=13p pd=50.52u as=13p ps=50.52u w=50u l=0.7u
X1103 HS_N_9 HS_PBIAS VDD VDD pfet_03v3 ad=8.8p pd=40.88u as=8.8p ps=40.88u w=20u l=1u
X1104 a_41684_220611# a_41684_220611# a_41684_232275# VSS nfet_06v0 ad=13p pd=50.52u as=13p ps=50.52u w=50u l=0.7u
X1105 a_42245_162628# VSS VSS ppolyf_u_1k_6p0 r_width=1u r_length=99.24u
X1106 a_41684_220611# ESD_RAIL ESD_RAIL VSS nfet_06v0 ad=13p pd=50.52u as=13p ps=50.52u w=50u l=0.7u
X1107 VSS a_41684_232275# a_41684_232275# VSS nfet_06v0 ad=13p pd=50.52u as=13p ps=50.52u w=50u l=0.7u
X1108 a_41684_232275# a_41684_220611# a_41684_220611# VSS nfet_06v0 ad=13p pd=50.52u as=13p ps=50.52u w=50u l=0.7u
X1109 TERM_OR_P_B TERM_ENABLE VSS VSS nfet_03v3 ad=0.88p pd=4.88u as=0.88p ps=4.88u w=2u l=0.28u
X1110 a_41684_232275# a_41684_232275# VSS VSS nfet_06v0 ad=13p pd=50.52u as=13p ps=50.52u w=50u l=0.7u
X1111 VSS a_41684_232275# a_41684_232275# VSS nfet_06v0 ad=13p pd=50.52u as=13p ps=50.52u w=50u l=0.7u
X1112 a_41684_220611# ESD_RAIL ESD_RAIL VSS nfet_06v0 ad=13p pd=50.52u as=13p ps=50.52u w=50u l=0.7u
X1113 ESD_RAIL ESD_RAIL a_41684_220611# VSS nfet_06v0 ad=13p pd=50.52u as=13p ps=50.52u w=50u l=0.7u
X1114 a_41684_220611# ESD_RAIL ESD_RAIL VSS nfet_06v0 ad=13p pd=50.52u as=13p ps=50.52u w=50u l=0.7u
X1115 ESD_RAIL a_42245_162628# VSS VSS nfet_06v0 ad=22p pd=0.10088m as=13p ps=50.52u w=50u l=0.7u
X1116 TERM_P_R DIFF_ENABLE TERM_N_R VSS nfet_03v3 ad=8.8p pd=40.88u as=8.8p ps=40.88u w=20u l=0.28u
X1117 a_41684_220611# ESD_RAIL ESD_RAIL VSS nfet_06v0 ad=13p pd=50.52u as=13p ps=50.52u w=50u l=0.7u
X1118 ESD_RAIL a_53878_206345# ESD_RAIL ppolyf_u r_width=0.8u r_length=63.855u
X1119 VSS a_41684_232275# a_41684_232275# VSS nfet_06v0 ad=13p pd=50.52u as=13p ps=50.52u w=50u l=0.7u
X1120 a_41684_232275# a_41684_220611# a_41684_220611# VSS nfet_06v0 ad=13p pd=50.52u as=13p ps=50.52u w=50u l=0.7u
X1121 a_41684_220611# ESD_RAIL ESD_RAIL VSS nfet_06v0 ad=13p pd=50.52u as=13p ps=50.52u w=50u l=0.7u
X1122 TERM_OR_P_NS VCM_LOW_OK VSS VSS nfet_03v3 ad=1.76p pd=8.88u as=1.76p ps=8.88u w=4u l=0.28u
X1123 FS_N_OUT FS_N_GATE FS_N_WELL FS_N_WELL pfet_03v3 ad=6.16p pd=28.88u as=6.16p ps=28.88u w=14u l=0.28u
X1124 a_41684_232275# a_41684_232275# VSS VSS nfet_06v0 ad=13p pd=50.52u as=13p ps=50.52u w=50u l=0.7u
X1125 a_41684_220611# a_41684_220611# a_41684_232275# VSS nfet_06v0 ad=13p pd=50.52u as=13p ps=50.52u w=50u l=0.7u
X1126 a_41684_220611# a_41684_220611# a_41684_232275# VSS nfet_06v0 ad=13p pd=50.52u as=13p ps=50.52u w=50u l=0.7u
X1127 TERM_GATE_P_BLEED_1 TERM_GATE_P_BLEED_2 VSS ppolyf_u_1k r_width=1u r_length=12.5u
X1128 a_41684_232275# a_41684_220611# a_41684_220611# VSS nfet_06v0 ad=13p pd=50.52u as=13p ps=50.52u w=50u l=0.7u
X1129 a_41684_220611# ESD_RAIL ESD_RAIL VSS nfet_06v0 ad=13p pd=50.52u as=13p ps=50.52u w=50u l=0.7u
X1130 HS_N_11 HS_N PAD_N VSS nfet_06v0 ad=8.8p pd=40.88u as=8.8p ps=40.88u w=20u l=0.7u
X1131 VSS a_41684_232275# a_41684_232275# VSS nfet_06v0 ad=13p pd=50.52u as=13p ps=50.52u w=50u l=0.7u
X1132 a_41684_232275# a_41684_220611# a_41684_220611# VSS nfet_06v0 ad=13p pd=50.52u as=13p ps=50.52u w=50u l=0.7u
X1133 a_41684_232275# a_41684_232275# VSS VSS nfet_06v0 ad=13p pd=50.52u as=13p ps=50.52u w=50u l=0.7u
X1134 a_41684_220611# a_41684_220611# a_41684_232275# VSS nfet_06v0 ad=13p pd=50.52u as=22p ps=0.10088m w=50u l=0.7u
X1135 ESD_RAIL ESD_RAIL a_41684_220611# VSS nfet_06v0 ad=13p pd=50.52u as=13p ps=50.52u w=50u l=0.7u
X1136 HS_N_0 HS_N PAD_N VSS nfet_06v0 ad=8.8p pd=40.88u as=8.8p ps=40.88u w=20u l=0.7u
X1137 ESD_RAIL ESD_RAIL a_41684_220611# VSS nfet_06v0 ad=13p pd=50.52u as=13p ps=50.52u w=50u l=0.7u
X1138 PAD_N BYPASS_ENABLE RX_N VSS nfet_06v0 ad=8.8p pd=40.88u as=8.8p ps=40.88u w=20u l=0.7u
X1139 VDD FS_P_GATE FS_P_WELL FS_P_WELL pfet_03v3 ad=6.16p pd=28.88u as=6.16p ps=28.88u w=14u l=0.28u
X1140 a_41684_220611# ESD_RAIL ESD_RAIL VSS nfet_06v0 ad=13p pd=50.52u as=13p ps=50.52u w=50u l=0.7u
X1141 PAD_N BYPASS_ENABLE RX_N VSS nfet_06v0 ad=8.8p pd=40.88u as=8.8p ps=40.88u w=20u l=0.7u
X1142 ESD_RAIL ESD_RAIL a_41684_220611# VSS nfet_06v0 ad=13p pd=50.52u as=13p ps=50.52u w=50u l=0.7u
X1143 a_41684_220611# ESD_RAIL ESD_RAIL VSS nfet_06v0 ad=13p pd=50.52u as=13p ps=50.52u w=50u l=0.7u
X1144 ESD_RAIL ESD_RAIL a_41684_220611# VSS nfet_06v0 ad=13p pd=50.52u as=13p ps=50.52u w=50u l=0.7u
X1145 PULLUP_N_BLEED_2 PULLUP_N_BLEED_3 VSS ppolyf_u_1k r_width=1u r_length=12.5u
X1146 a_41684_232275# a_41684_220611# a_41684_220611# VSS nfet_06v0 ad=13p pd=50.52u as=13p ps=50.52u w=50u l=0.7u
X1147 a_41684_220611# a_41684_220611# a_41684_232275# VSS nfet_06v0 ad=13p pd=50.52u as=13p ps=50.52u w=50u l=0.7u
X1148 a_41684_220611# ESD_RAIL ESD_RAIL VSS nfet_06v0 ad=13p pd=50.52u as=13p ps=50.52u w=50u l=0.7u
X1149 ESD_RAIL a_42245_162628# VSS VSS nfet_06v0 ad=13p pd=50.52u as=13p ps=50.52u w=50u l=0.7u
C0 HS_N_8 HS_P_5 0.05893f
C1 DIV_N HS_N_9 0.03462f
C2 TERM_ENABLE HS_P_13 0.02404f
C3 TERM_GATE_P HS_P_12 0.16452f
C4 HS_N_7 PULLDOWN_P_R 0.02404f
C5 HS_N_13 HS_N_10 0.09129f
C6 TERM_ENABLE HS_PBIAS 0.73653f
C7 PULLUP_N_OUT TERM_OR_P_NS 0.11021f
C8 FS_LOW_N HS_N_9 0.08512f
C9 TERM_ENABLE PULLUP_P_WELL 2.34229f
C10 HS_N_6 TERM_GATE_N_BLEED_1 0.0525f
C11 PAD_P HS_N_4 0.06517f
C12 FS_LOW_P PULLUP_P_GATE 0.15193f
C13 TERM_OR_N_B HS_N_9 0
C14 HS_P_2 TERM_ENABLE 0.06392f
C15 TERM_GATE_P HS_P_13 0.15775f
C16 FS_N_BLEED_3 FS_N_BLEED_4 9.3821f
C17 TERM_GATE_P HS_PBIAS 0.02241f
C18 HS_P_9 HS_P_8 30.3927f
C19 TERM_GATE_N_BLEED_2 HS_N_11 0.02434f
C20 DIV_ENABLE TERM_GATE_N_BLEED_1 0
C21 TERM_GATE_N PULLDOWN_N_R 0.12021f
C22 FS_LOW_P TERM_GATE_N_BLEED_0 0.06271f
C23 FS_LOW_P HS_N_4 0.08505f
C24 HS_P_3 HS_N_0 0.02686f
C25 a_53878_204105# ESD_RAIL 0.53942f
C26 HS_N_6 HS_P_4 0.03738f
C27 FS_P_BLEED_1 FS_HIGH_P 0.16649f
C28 HS_P_2 TERM_GATE_P 0.15718f
C29 VDD VCM_LOW_OK 57.507f
C30 VDD FS_P_WELL 99.794f
C31 PULLUP_P_BLEED_5 HS_N_0 0.02492f
C32 TERM_ENABLE DIFF_ENABLE 0.17128f
C33 PULLUP_P_BLEED_4 PULLUP_P_GATE 0.10639f
C34 HS_N TERM_VCM 0.21341f
C35 FS_N_BLEED_2 FS_HIGH_N 0.00429f
C36 FS_N_CONTROL_S TERM_P_R 0.11557f
C37 HS_P_3 HS_N_2 0.02451f
C38 PULLDOWN_N_R TERM_N_R 0.12913f
C39 DIV_N VCM_LOW_OK 0.00178f
C40 VDD PAD_N 0.00457f
C41 FS_LOW_P FS_N_GATE 0.45819f
C42 DIV_N FS_P_WELL 0.86039f
C43 HS_P_9 HS_P_5 0
C44 PULLUP_P_BLEED_4 HS_N_4 0.0525f
C45 HS_N_2 PULLUP_P_BLEED_5 0.02404f
C46 TERM_P_R HS_N_13 0.0965f
C47 HS_PBIAS PULLUP_P_BLEED_6 0.01633f
C48 DIV_N PAD_N 0.68859f
C49 HS_N HS_P_1 0.75007f
C50 HS_N_8 HS_P_11 0.02857f
C51 FS_LOW_N VCM_LOW_OK 0.22495f
C52 TERM_OR_N_B VCM_LOW_OK 2.86687f
C53 PAD_P HS_P_6 1.8306f
C54 HS_N FS_N_BLEED_0 0.11535f
C55 TERM_GATE_N HS_N_11 0.04856f
C56 FS_HIGH_N FS_N_BLEED_5 0.00933f
C57 FS_P_BLEED_1 HS_PBIAS 0.04811f
C58 TERM_VCM PULLUP_P_OUT 0.36501f
C59 PULLDOWN_P_R PULLDOWN_N_R 33.296f
C60 HS_N FS_P_CONTROL_S 0.04342f
C61 FS_HIGH_P FS_N_OUT 0.17276f
C62 DIV_LOW_P FS_N_OUT 0.05525f
C63 FS_P_WELL BYPASS_ENABLE 0.05062f
C64 TERM_OR_N_S PULLUP_N_OUT 0.13603f
C65 HS_N_0 PULLUP_N_OUT 0.05062f
C66 HS_P_12 TERM_OR_P_B 0.13059f
C67 FS_LOW_P HS_P_6 0.04566f
C68 FS_P_BLEED_1 PULLUP_P_WELL 0.00137f
C69 TERM_GATE_P_BLEED_0 HS_N_9 0.00105f
C70 PULLUP_N_BLEED_5 PULLUP_P 0.10721f
C71 PULLUP_N_GATE PULLUP_N_BLEED_1 0.05777f
C72 BYPASS_ENABLE PAD_N 11.6896f
C73 FS_LOW_P PULLUP_P 0.10849f
C74 PULLUP_P_GATE HS_N_9 0.08704f
C75 FS_N_GATE FS_N_WELL 0.29032p
C76 PULLUP_N_BLEED_6 TERM_VCM 0.04263f
C77 TERM_VCM PULLUP_P_BLEED_2 0.08967f
C78 HS_N_11 TERM_N_R 0.05996f
C79 HS_P_13 TERM_OR_P_B 0.10389f
C80 HS_N_8 TERM_GATE_N_BLEED_2 0.04243f
C81 VDD FS_N_BLEED_1 0.00299f
C82 FS_N_OUT HS_P_12 0.12335f
C83 TERM_GATE_N_BLEED_0 HS_N_9 0.03489f
C84 HS_N_4 HS_N_9 0.04068f
C85 PAD_P HS_N_12 2.18792f
C86 FS_P_BLEED_4 FS_N_OUT 0.06639f
C87 VDD HS_P_3 6.14484f
C88 PULLUP_N PULLUP_N_BLEED_2 0.29902f
C89 TERM_GATE_N_BLEED_1 PULLDOWN_P 0.07928f
C90 HS_P_2 TERM_OR_P_B 0.10307f
C91 PULLUP_P_BLEED_4 PULLUP_P 0.16921f
C92 PAD_P HS_N_1 0.48214f
C93 FS_LOW_P HS_N_12 0.08505f
C94 HS_PBIAS FS_N_OUT 0.93576f
C95 FS_N_BLEED_3 PULLDOWN_P 0.08856f
C96 HS_N_3 TERM_ENABLE 0.04808f
C97 FS_LOW_N FS_N_BLEED_1 0.00106f
C98 HS_P_11 HS_P_9 0.00817f
C99 HS_N_11 PULLDOWN_P_R 0.02429f
C100 HS_N_7 HS_P_7 0
C101 PULLUP_P_WELL FS_N_OUT 0.13784f
C102 FS_N_GATE HS_N_9 0.01367f
C103 DIV_LOW_N HS_N 0.08856f
C104 HS_N_7 FS_P_BLEED_5 0.06178f
C105 HS_N_1 FS_LOW_P 0.21255f
C106 HS_P_5 HS_N_10 0.03489f
C107 FS_N_WELL PULLUP_P 1.86538f
C108 PULLUP_N_WELL PULLUP_N_GATE 33.5703f
C109 PULLUP_P_BLEED_5 FS_LOW_N 0.02437f
C110 HS_N_3 TERM_GATE_P 0.11104f
C111 PULLUP_P_GATE VCM_LOW_OK 0.22296f
C112 FS_HIGH_P HS_N_13 0.02404f
C113 DIV_LOW_P HS_N_13 0.00103f
C114 PULLUP_P_BLEED_4 HS_N_12 0.05263f
C115 HS_N_8 TERM_GATE_N 0.05073f
C116 HS_N_4 VCM_LOW_OK 0.05893f
C117 FS_P_BLEED_1 FS_P_BLEED_2 1.41312f
C118 HS_N_4 FS_P_WELL 1.9794f
C119 TERM_P_R HS_P_8 0.08296f
C120 HS_P_6 HS_N_9 0.05493f
C121 HS_P_0 TERM_ENABLE 0.03037f
C122 VDD PULLUP_N_OUT 5.43573f
C123 FS_N_WELL HS_N_12 0.00912f
C124 HS_N_1 PULLUP_P_BLEED_4 0.05286f
C125 PULLUP_P HS_N_9 0.02404f
C126 HS_N_4 PAD_N 1.29614f
C127 PULLUP_N_WELL PULLUP_N_BLEED_1 0.00587f
C128 HS_P_12 HS_N_13 0.03621f
C129 FS_N_CONTROL_S HS_PBIAS 0.09439f
C130 DIV_N PULLUP_N_OUT 0.04377f
C131 FS_P_BLEED_4 HS_N_13 0.06178f
C132 HS_N_8 TERM_N_R 0.05914f
C133 TERM_GATE_P_BLEED_2 PULLUP_P_OUT 0.04242f
C134 TERM_GATE_P HS_P_0 0.25837f
C135 HS_P_13 HS_N_13 0.0245f
C136 FS_LOW_N PULLUP_N_OUT 0.06432f
C137 HS_N FS_HIGH_N 0.06561f
C138 FS_P_OUT DIV_P 0.01279f
C139 HS_PBIAS HS_N_13 7.29451f
C140 PULLUP_N_OUT TERM_OR_N_B 0.09609f
C141 PULLUP_P_WELL HS_N_13 0.12105f
C142 HS_P_7 PULLDOWN_N_R 0.02418f
C143 TERM_P_R HS_P_5 0.08374f
C144 HS_N_12 HS_N_9 0.02504f
C145 HS_N HS_P_10 0.34498f
C146 HS_N_3 FS_P_BLEED_1 0.03472f
C147 FS_N_BLEED_6 HS_PBIAS 0.09349f
C148 FS_N_OUT FS_P_BLEED_2 0.15927f
C149 HS_N_8 PULLDOWN_P_R 0.02404f
C150 HS_P_11 HS_N_10 0.00351f
C151 PULLDOWN_N_R TERM_GATE_P_BLEED_1 0.00195f
C152 TERM_GATE_P_BLEED_0 HS_P_3 0.02464f
C153 FS_P_BLEED_5 PULLDOWN_N_R 0.10378f
C154 VCM_LOW_OK HS_P_6 0.03489f
C155 PAD_P HS_N_5 0.34243f
C156 FS_LOW_P PULLUP_P_BLEED_3 0.07139f
C157 HS_N_6 HS_N_7 0.12041p
C158 PULLUP_P VCM_LOW_OK 0.08753f
C159 HS_P_6 PAD_N 0.31264f
C160 DIV_ENABLE HS_N_7 0.03089f
C161 PAD_P HS_P 39.8004f
C162 HS_N_3 TERM_OR_P_B 0.07211f
C163 FS_LOW_P HS_N_5 0.08533f
C164 PULLUP_P_GATE PULLUP_P_BLEED_5 0.2056f
C165 HS_P_3 HS_N_4 0.00972f
C166 HS_P_10 PULLUP_P_OUT 0.05276f
C167 TERM_ENABLE TERM_VCM 0.55694f
C168 PULLUP_N_BLEED_6 FS_HIGH_N 0.15562f
C169 HS_N FS_N_BLEED_2 0.11535f
C170 TERM_OR_N_S TERM_OR_N_NS 0.00164f
C171 FS_LOW_P PULLUP_P_CONTROL_S 0.05888f
C172 PULLUP_P_BLEED_5 HS_N_4 0.02921f
C173 HS_N_0 FS_P_BLEED_6 0.06178f
C174 TERM_GATE_N_BLEED_2 HS_N_10 0.02441f
C175 TERM_OR_N_NS HS_N_0 0.03425f
C176 FS_LOW_P HS_P 0.09863f
C177 FS_N_GATE FS_N_BLEED_1 0.29846f
C178 HS_N_3 FS_N_OUT 0.06167f
C179 TERM_ENABLE HS_P_1 0.02404f
C180 PULLUP_P_BLEED_4 PULLUP_P_BLEED_3 6.29036f
C181 HS_N_12 FS_P_WELL 2.00803f
C182 TERM_GATE_P TERM_VCM 26.4481f
C183 VCM_LOW_OK HS_N_12 0.05893f
C184 PULLUP_P_BLEED_4 HS_N_5 0.0525f
C185 HS_N FS_N_BLEED_5 0.02443f
C186 HS_N_11 FS_P_BLEED_5 0.06178f
C187 HS_N_2 FS_P_BLEED_6 0.06178f
C188 HS_N_2 TERM_OR_N_NS 0.03425f
C189 PULLUP_N_BLEED_5 PULLUP_N_BLEED_2 0.00296f
C190 HS_P_0 TERM_OR_P_B 0.09384f
C191 HS_P_11 TERM_P_R 0.14852f
C192 HS_N_12 PAD_N 1.21768f
C193 TERM_GATE_P HS_P_1 0.25434f
C194 TERM_GATE_P_BLEED_0 PULLUP_N_OUT 0.10679f
C195 HS_N_1 VCM_LOW_OK 0.05893f
C196 HS_N_1 FS_P_WELL 2.10428f
C197 DIV_ENABLE PULLUP_N_BLEED_0 0
C198 PULLDOWN_P_R HS_P_9 0.07466f
C199 PULLUP_P_BLEED_4 HS_P 0.0525f
C200 HS_P_8 HS_P_12 0
C201 a_53878_204665# a_53878_204105# 0.0346f
C202 PULLUP_P_GATE PULLUP_N_OUT 0.36087f
C203 TERM_GATE_N_BLEED_0 PULLUP_N_OUT 0.05462f
C204 HS_N_1 PAD_N 1.13339f
C205 RX_N DIV_P 0.37599f
C206 PULLUP_P PULLUP_N_BLEED_3 0.05126f
C207 FS_N_BLEED_1 PULLUP_P 0.04819f
C208 HS_P_3 HS_P_6 0.07261f
C209 HS_P_8 HS_P_13 0.05624f
C210 DIV_LOW_P HS_P_5 0.00305f
C211 FS_N_WELL HS_P 2.92153f
C212 HS_N_4 PULLUP_N_OUT 0.01742f
C213 HS_N_6 PULLDOWN_N_R 0.06832f
C214 HS_PBIAS HS_P_8 1.54227f
C215 FS_N_BLEED_4 PULLDOWN_N_R 0.04811f
C216 VDD PULLUP_P_BLEED_0 0.05459f
C217 TERM_GATE_N HS_N_10 0.04869f
C218 PULLUP_P_BLEED_3 HS_N_9 0.03489f
C219 HS_N_0 DIV_P 0.03388f
C220 PULLUP_P_BLEED_5 PULLUP_P 0.15607f
C221 DIV_ENABLE PULLDOWN_N_R 0.04455f
C222 HS_P_2 HS_P_8 0.03103f
C223 FS_N_GATE PULLUP_N_OUT 1.02928f
C224 HS_N_5 HS_N_9 0.04079f
C225 RX_N FS_P_OUT 0.00505f
C226 FS_P_BLEED_1 TERM_VCM 0.03472f
C227 FS_P_GATE TERM_N_R 0.81322f
C228 HS_P_5 HS_P_12 0.03887f
C229 HS_N_7 PULLDOWN_P 0.04428f
C230 HS_N_3 HS_N_13 0.279f
C231 DIV_LOW_N TERM_ENABLE 0.07174f
C232 VDD FS_P_BLEED_6 0.01345f
C233 VDD TERM_OR_N_NS 0.44386f
C234 TERM_N_R HS_N_10 0.06034f
C235 HS_P HS_N_9 0.12097p
C236 HS_P_5 HS_P_13 0.26928f
C237 PULLUP_P_CONTROL_S HS_N_9 0.04808f
C238 FS_P_BLEED_5 FS_P_BLEED_3 0.12036f
C239 PULLUP_N_BLEED_4 PULLDOWN_P 0
C240 HS_P_3 HS_N_12 0.02482f
C241 PULLUP_N_CONTROL_S PULLUP_N 1.30292f
C242 HS_N_0 FS_P_OUT 0.5609f
C243 HS_N_8 HS_P_7 0.09182f
C244 VDD PULLUP_N_GATE 11.92f
C245 HS_PBIAS HS_P_5 3.80328f
C246 PULLUP_P_BLEED_5 HS_N_12 0.02427f
C247 TERM_VCM TERM_OR_P_B 0.06303f
C248 TERM_ENABLE TERM_GATE_P_BLEED_2 0.07306f
C249 FS_P_GATE PULLDOWN_P_R 1.57717f
C250 DIV_N TERM_OR_N_NS 0
C251 FS_P_BLEED_1 FS_P_CONTROL_S 0
C252 HS_N_6 HS_N_11 0
C253 PULLUP_N_OUT HS_P_6 0.02846f
C254 HS_P_2 HS_P_5 0.03142f
C255 HS_N_1 HS_P_3 0.02599f
C256 HS_N_8 FS_P_BLEED_5 0.06178f
C257 TERM_OR_N_NS FS_LOW_N 3.62207f
C258 FS_P_BLEED_0 HS_N_7 0.06178f
C259 HS_N_1 PULLUP_P_BLEED_5 0.02451f
C260 TERM_OR_P_B HS_P_1 0.08191f
C261 PULLUP_N_OUT PULLUP_P 29.6105f
C262 HS_N_2 FS_P_OUT 0.43576f
C263 PULLDOWN_P_R HS_N_10 0.02436f
C264 FS_LOW_N PULLUP_N_GATE 0.17511f
C265 TERM_VCM FS_N_OUT 0.42885f
C266 PULLUP_P_BLEED_3 VCM_LOW_OK 0.03823f
C267 DIV_ENABLE HS_N_11 0.03161f
C268 TERM_OR_N_NS TERM_OR_N_B 1.66751f
C269 PULLDOWN_P PULLUP_N_BLEED_0 0.06517f
C270 TERM_GATE_N TERM_P_R 0.1818f
C271 TERM_GATE_P TERM_GATE_P_BLEED_2 0.40344f
C272 HS_N_5 VCM_LOW_OK 0.05893f
C273 HS_N_5 FS_P_WELL 1.97115f
C274 HS_N_5 PAD_N 1.1645f
C275 HS_P FS_P_WELL 2.08315f
C276 TERM_ENABLE FS_HIGH_N 0.05082f
C277 VCM_LOW_OK HS_P 0.06526f
C278 HS_P_11 HS_P_12 46.9655f
C279 PULLUP_N_OUT HS_N_12 0.04377f
C280 VDD DIV_P 0.11168f
C281 TERM_P_R TERM_N_R 28.0337f
C282 HS_P PAD_N 1.82419f
C283 TERM_ENABLE HS_P_10 0.0768f
C284 FS_P_CONTROL_S FS_N_OUT 0.00663f
C285 HS_P_11 HS_P_13 0.08851f
C286 HS_P_11 HS_PBIAS 9.38284f
C287 HS_P_9 HS_P_7 0.00206f
C288 PULLDOWN_P PULLDOWN_N_R 88.82401f
C289 DIV_N DIV_P 48.6079f
C290 TERM_GATE_P HS_P_10 0.17903f
C291 HS_N PULLUP_P_OUT 0.04828f
C292 TERM_VCM FS_N_CONTROL_S 0.07594f
C293 PULLUP_P_GATE PULLUP_P_BLEED_0 0.16374f
C294 HS_P_2 HS_P_11 0.00106f
C295 PULLDOWN_P_R TERM_P_R 0.16322f
C296 HS_N_6 FS_P_BLEED_3 0.03529f
C297 VDD FS_P_OUT 10.8417f
C298 VDD PULLUP_N_WELL 25.2292f
C299 TERM_VCM HS_N_13 0.17f
C300 TERM_ENABLE FS_N_BLEED_2 0.08954f
C301 RX_N HS_N_0 0.00305f
C302 HS_N_6 HS_N_8 0.04151f
C303 DIV_N FS_P_OUT 0.05123f
C304 FS_LOW_P TERM_GATE_N_BLEED_1 0.05872f
C305 DIV_P BYPASS_ENABLE 0.05958f
C306 HS_N PULLUP_N_BLEED_6 0.06167f
C307 FS_P_BLEED_0 PULLDOWN_N_R 0.10124f
C308 HS_P_3 HS_N_5 0.03089f
C309 FS_LOW_P FS_N_BLEED_3 0.10387f
C310 DIV_ENABLE HS_N_8 0.03089f
C311 PAD_P HS_P_4 1.13663f
C312 PULLUP_P_GATE FS_P_BLEED_6 0.023f
C313 TERM_GATE_N_BLEED_2 HS_PBIAS 0.17672f
C314 PULLUP_P_BLEED_5 PULLUP_P_BLEED_3 0.00153f
C315 TERM_GATE_P_BLEED_2 TERM_OR_P_B 0.00349f
C316 DIV_LOW_N FS_N_OUT 0.11535f
C317 FS_N_BLEED_1 HS_P 0.08856f
C318 TERM_OR_N_S HS_N_0 0.02686f
C319 FS_LOW_N PULLUP_N_WELL 0.20869f
C320 PULLDOWN_P HS_N_11 0.05266f
C321 HS_N_5 PULLUP_P_BLEED_5 0.03089f
C322 HS_N_4 FS_P_BLEED_6 0.06178f
C323 TERM_OR_N_NS HS_N_4 0.03425f
C324 FS_HIGH_P TERM_GATE_N 0.00415f
C325 FS_LOW_P HS_P_4 0.04599f
C326 HS_P_3 HS_P 1.89056f
C327 VDD TERM_OR_P_NS 0.04366f
C328 HS_N_3 HS_P_5 0.03489f
C329 PULLUP_P_BLEED_5 HS_P 0.10446f
C330 FS_P_CONTROL_S HS_N_13 0.03226f
C331 PULLUP_N_BLEED_3 PULLUP_N_BLEED_2 0.39425f
C332 PULLUP_N_WELL BYPASS_ENABLE 0.01588f
C333 TERM_OR_N_S HS_N_2 0.02451f
C334 HS_N_2 HS_N_0 0.04171f
C335 FS_HIGH_P TERM_N_R 0.01124f
C336 FS_P_BLEED_0 HS_N_11 0.06178f
C337 FS_P_GATE FS_P_BLEED_5 0.31234f
C338 FS_N_BLEED_3 FS_N_WELL 0.1181f
C339 PULLUP_P PULLUP_P_BLEED_0 0.82084f
C340 PULLUP_P_BLEED_3 PULLUP_N_OUT 0.05476f
C341 PULLUP_N_BLEED_4 PULLUP_N 0.08101f
C342 HS_N_5 PULLUP_N_OUT 0.04773f
C343 FS_P_BLEED_5 HS_N_10 0.06178f
C344 TERM_GATE_N HS_PBIAS 0.13841f
C345 FS_HIGH_N FS_N_OUT 0.03054f
C346 HS_P_10 TERM_OR_P_B 0.09644f
C347 HS_P_0 HS_P_5 0.00297f
C348 FS_HIGH_P PULLDOWN_P_R 0.04377f
C349 PULLUP_N_OUT HS_P 0.09327f
C350 PULLUP_N_OUT PULLUP_P_CONTROL_S 0.08753f
C351 TERM_GATE_N_BLEED_1 HS_N_9 0.0525f
C352 TERM_OR_N_NS PULLUP_P 0.05397f
C353 DIV_LOW_N HS_N_13 0.06178f
C354 PULLUP_P PULLUP_N_GATE 1.42018f
C355 HS_PBIAS TERM_N_R 0.70629f
C356 PULLUP_N_BLEED_0 PULLUP_N 0.85278f
C357 DIV_N RX_N 1.36638f
C358 PULLUP_P_WELL TERM_N_R 0.33634f
C359 TERM_VCM HS_P_8 0.09671f
C360 VDD TERM_OR_N_S 10.1707f
C361 PULLDOWN_P_R HS_P_12 0.02404f
C362 VDD HS_N_0 4.91768f
C363 HS_P_4 HS_N_9 0.03089f
C364 PULLDOWN_P_R FS_P_BLEED_4 0.08089f
C365 HS_P_7 TERM_P_R 0.08343f
C366 RX_P FS_N_OUT 0.01284f
C367 PULLDOWN_P_R HS_P_13 0.02404f
C368 HS_N_4 FS_P_OUT 0.43331f
C369 FS_P_BLEED_6 HS_N_12 0.06178f
C370 TERM_OR_N_NS HS_N_12 0.03425f
C371 HS_P_8 HS_P_1 0.02404f
C372 PULLDOWN_P_R HS_PBIAS 0.50594f
C373 TERM_P_R TERM_GATE_P_BLEED_1 0.00257f
C374 DIV_N HS_N_0 0.03952f
C375 FS_N_CONTROL_S FS_HIGH_N 7.6088f
C376 TERM_OR_N_S FS_LOW_N 0.4405f
C377 HS_N_0 FS_LOW_N 0.08452f
C378 PULLDOWN_N PULLUP_N_GATE 0.00151f
C379 DIFF_ENABLE TERM_N_R 6.47766f
C380 RX_N BYPASS_ENABLE 7.14256f
C381 PULLDOWN_P_R PULLUP_P_WELL 0.59282f
C382 VDD HS_N_2 5.27157f
C383 PULLDOWN_N_R PULLUP_N 0.00106f
C384 HS_N_1 FS_P_BLEED_6 0.06178f
C385 HS_N_6 FS_P_GATE 1.04254f
C386 HS_N_1 TERM_OR_N_NS 0.03425f
C387 FS_P_BLEED_0 HS_N_8 0.06178f
C388 HS_P_2 PULLDOWN_P_R 0.07466f
C389 TERM_OR_N_S TERM_OR_N_B 4.08319f
C390 TERM_VCM HS_P_5 0.09615f
C391 HS_P_0 HS_P_11 0.06445f
C392 HS_N_3 TERM_GATE_N_BLEED_2 0.02807f
C393 DIV_N HS_N_2 0.03462f
C394 HS_P_6 DIV_P 0.03388f
C395 HS_N TERM_ENABLE 0.07737f
C396 a_53878_206345# ESD_RAIL 0.5677f
C397 HS_N_6 HS_N_10 0
C398 DIV_ENABLE FS_P_GATE 0.00424f
C399 HS_P_5 HS_P_1 0.02411f
C400 HS_N_2 FS_LOW_N 0.08441f
C401 DIV_ENABLE HS_N_10 0.03182f
C402 HS_N_4 TERM_OR_P_NS 0.00196f
C403 HS_N TERM_GATE_P 0.17562f
C404 VCM_LOW_OK HS_P_4 0.06673f
C405 FS_P_OUT HS_P_6 0.15673f
C406 TERM_ENABLE PULLUP_P_OUT 11.6132f
C407 HS_P_4 PAD_N 0.27735f
C408 PULLUP_P PULLUP_N_WELL 9.02284f
C409 PULLUP_P_BLEED_3 PULLUP_P_BLEED_0 0.0078f
C410 TERM_GATE_P PULLUP_P_OUT 0.40537f
C411 TERM_ENABLE PULLUP_N_BLEED_6 0.06151f
C412 HS_N_3 TERM_GATE_N 0.04808f
C413 TERM_ENABLE PULLUP_P_BLEED_2 0.11229f
C414 PAD_P HS_N_7 0.03829f
C415 DIV_N VDD 0.3598f
C416 HS_N_6 TERM_P_R 0.0959f
C417 HS_P_11 TERM_VCM 0.13824f
C418 TERM_P_R FS_N_BLEED_4 0.04766f
C419 FS_P_OUT HS_N_12 0.43801f
C420 TERM_OR_P_NS HS_P_6 0.02846f
C421 FS_LOW_P HS_N_7 0.0855f
C422 FS_N_BLEED_3 FS_N_BLEED_1 0.10633f
C423 PULLUP_P_BLEED_0 PULLUP_P_CONTROL_S 0.00275f
C424 VDD FS_LOW_N 2.24028f
C425 PULLUP_N_BLEED_4 PULLUP_N_BLEED_5 3.06975f
C426 FS_P_BLEED_1 HS_N 0.04405f
C427 DIV_ENABLE TERM_P_R 0.05603f
C428 TERM_OR_N_S TERM_GATE_N_BLEED_0 0
C429 HS_N_3 TERM_N_R 0.05893f
C430 PULLUP_P_GATE HS_N_0 0.08394f
C431 HS_P_11 HS_P_1 0.05935f
C432 VDD TERM_OR_N_B 10.4444f
C433 HS_N_1 FS_P_OUT 0.44686f
C434 HS_P_7 HS_P_12 0.11376f
C435 DIV_N FS_LOW_N 0.03551f
C436 TERM_GATE_N_BLEED_0 HS_N_0 0.03489f
C437 TERM_OR_N_S HS_N_4 0.026f
C438 FS_N_BLEED_6 FS_N_BLEED_5 1.15313f
C439 HS_N_5 FS_P_BLEED_6 0.06178f
C440 HS_N_5 TERM_OR_N_NS 0.03425f
C441 HS_P_3 HS_P_4 33.6448f
C442 HS_N_0 HS_N_4 0.04165f
C443 VDD BYPASS_ENABLE 0.03959f
C444 HS_P_7 HS_P_13 0.14204f
C445 FS_P_BLEED_6 HS_P 0.06178f
C446 PULLUP_P_BLEED_4 HS_N_7 0.0525f
C447 TERM_OR_N_NS HS_P 0.03425f
C448 HS_N_2 PULLUP_P_GATE 0.08296f
C449 DIV_N BYPASS_ENABLE 0.09436f
C450 FS_LOW_N TERM_OR_N_B 2.73977f
C451 FS_P_BLEED_1 PULLUP_P_OUT 0.05902f
C452 HS_P_7 HS_PBIAS 0.78499f
C453 FS_P_BLEED_5 FS_P_BLEED_4 3.61839f
C454 HS_N TERM_OR_P_B 0.1311f
C455 TERM_GATE_N_BLEED_2 TERM_VCM 0.02153f
C456 TERM_GATE_N_BLEED_0 HS_N_2 0.03489f
C457 FS_LOW_P PULLUP_N_BLEED_0 0.05872f
C458 HS_N_3 PULLDOWN_P_R 0.02404f
C459 PULLUP_N_GATE HS_P 0.11746f
C460 a_41005_204945# a_41005_203545# 0
C461 HS_N_2 HS_N_4 0.00206f
C462 HS_P_2 HS_P_7 0.06184f
C463 FS_P_BLEED_5 HS_PBIAS 0.08856f
C464 HS_P_10 HS_P_8 0.00926f
C465 FS_P_BLEED_0 FS_P_GATE 0.16521f
C466 HS_N FS_N_OUT 1.15664f
C467 TERM_GATE_N_BLEED_1 PULLUP_N_OUT 0.09196f
C468 PULLUP_P_WELL FS_P_BLEED_5 0.00636f
C469 PULLUP_N_GATE PULLUP_N_BLEED_2 0.06702f
C470 TERM_OR_P_B PULLUP_P_OUT 0.19951f
C471 PAD_P PULLDOWN_N_R 1.40429f
C472 FS_N_BLEED_3 PULLUP_N_OUT 0.10124f
C473 FS_P_BLEED_0 HS_N_10 0.06178f
C474 HS_P_0 PULLDOWN_P_R 0.03037f
C475 HS_P PULLUP_N_BLEED_1 0.11785f
C476 PULLUP_N_OUT HS_P_4 0.0863f
C477 FS_LOW_P PULLDOWN_N_R 0.0629f
C478 HS_N_0 HS_P_6 0.06114f
C479 FS_N_OUT PULLUP_P_OUT 0.06167f
C480 HS_N_7 HS_N_9 0.04397f
C481 TERM_OR_N_S PULLUP_P 0.13572f
C482 VDD TERM_GATE_P_BLEED_0 0.12131f
C483 HS_P_10 HS_P_5 0.0481f
C484 FS_HIGH_P FS_N_BLEED_4 0.09418f
C485 HS_N_0 PULLUP_P 0.07466f
C486 FS_HIGH_P HS_N_6 0.02404f
C487 TERM_GATE_N TERM_VCM 24.8972f
C488 VDD PULLUP_P_GATE 13.1722f
C489 HS_P DIV_P 0.08005f
C490 DIV_ENABLE FS_HIGH_P 4.86829f
C491 PULLUP_N_BLEED_2 PULLUP_N_BLEED_1 1.89414f
C492 HS_N_2 HS_P_6 0.05876f
C493 PULLDOWN_P TERM_P_R 0.04141f
C494 DIV_ENABLE DIV_LOW_P 2.67093f
C495 VDD TERM_GATE_N_BLEED_0 0.45815f
C496 HS_N_2 PULLUP_P 0.02404f
C497 VDD HS_N_4 6.4024f
C498 HS_N_5 FS_P_OUT 0.43331f
C499 PULLUP_P_BLEED_4 PULLDOWN_N_R 0.09196f
C500 HS_N FS_N_CONTROL_S 0.12118f
C501 DIV_N PULLUP_P_GATE 0.00178f
C502 TERM_OR_N_S HS_N_12 0.02482f
C503 HS_N_6 HS_P_12 0.06578f
C504 PULLUP_N_OUT PULLUP_N_CONTROL_S 0.004f
C505 PAD_P HS_N_11 0.38848f
C506 TERM_VCM TERM_N_R 17.5283f
C507 HS_N_0 HS_N_12 0.04188f
C508 DIV_N TERM_GATE_N_BLEED_0 0.10151f
C509 HS_N_6 FS_P_BLEED_4 0.06231f
C510 FS_P_OUT HS_P 0.68531f
C511 a_41005_205505# a_41005_206065# 0.0346f
C512 DIV_N HS_N_4 0.03462f
C513 FS_N_WELL PULLDOWN_N_R 2.17407f
C514 a_53878_205785# ESD_RAIL 0.53942f
C515 HS_N_6 HS_P_13 0.05493f
C516 TERM_GATE_N_BLEED_0 FS_LOW_N 0.07127f
C517 HS_N HS_N_13 0.98202f
C518 a_41005_203545# m2_42279_196800# 0.05457f
C519 HS_N_1 TERM_OR_N_S 0.02599f
C520 FS_LOW_P HS_N_11 0.08505f
C521 HS_N_4 FS_LOW_N 0.08441f
C522 VDD FS_N_GATE 23.571f
C523 HS_PBIAS FS_N_BLEED_4 0.04811f
C524 PULLUP_N_WELL HS_P 0.25435f
C525 FS_P_BLEED_0 TERM_P_R 0.11348f
C526 HS_N_1 HS_N_0 0.12498p
C527 TERM_GATE_N_BLEED_0 TERM_OR_N_B 0.00163f
C528 HS_N_6 HS_PBIAS 7.23511f
C529 FS_P_BLEED_5 FS_P_BLEED_2 0.12885f
C530 HS_N_7 VCM_LOW_OK 0.05893f
C531 HS_N_7 FS_P_WELL 1.98759f
C532 HS_N_2 HS_N_12 0.02585f
C533 HS_N FS_N_BLEED_6 0.07097f
C534 DIV_ENABLE HS_PBIAS 0.05806f
C535 HS_N_6 PULLUP_P_WELL 0.12108f
C536 TERM_GATE_P TERM_ENABLE 1.60491f
C537 TERM_GATE_N_BLEED_0 BYPASS_ENABLE 0.00766f
C538 PULLDOWN_P_R TERM_VCM 0.22328f
C539 HS_P_2 HS_N_6 0.03089f
C540 HS_N_5 TERM_OR_P_NS 0.00258f
C541 FS_N_GATE FS_LOW_N 0.72441f
C542 DIV_ENABLE PULLUP_P_WELL 0.01343f
C543 HS_N_7 PAD_N 1.7635f
C544 TERM_P_R PULLUP_P_BLEED_1 0.04588f
C545 PULLUP_N_WELL PULLUP_N_BLEED_2 0.00114f
C546 HS_P_10 HS_P_11 48.3384f
C547 HS_N_1 HS_N_2 0.00962f
C548 HS_N_13 PULLUP_P_OUT 0.03489f
C549 PULLUP_P_BLEED_4 HS_N_11 0.05266f
C550 PULLDOWN_P_R HS_P_1 0.08595f
C551 PULLDOWN_N_R HS_N_9 0.02404f
C552 TERM_OR_P_NS HS_P 0.04056f
C553 VDD HS_P_6 6.8233f
C554 VDD PULLUP_P 2.21994f
C555 DIV_N HS_P_6 0
C556 HS_N_11 FS_N_WELL 0.00889f
C557 TERM_ENABLE PULLUP_P_BLEED_6 0
C558 DIV_ENABLE DIFF_ENABLE 5.44387f
C559 HS_N_3 FS_P_BLEED_5 0.06178f
C560 DIV_N PULLUP_P 0.04512f
C561 DIV_LOW_N TERM_GATE_N 0.06956f
C562 FS_LOW_N PULLUP_P 0.06432f
C563 PULLUP_P TERM_OR_N_B 0.09232f
C564 FS_P_BLEED_1 TERM_ENABLE 0.05902f
C565 PAD_P HS_N_8 0.43522f
C566 HS_P_0 HS_P_7 0.00469f
C567 VDD HS_N_12 6.63266f
C568 PULLUP_N_BLEED_4 PULLUP_N_BLEED_3 1.53214f
C569 a_41005_204385# a_41005_204945# 0.0346f
C570 HS_N_11 HS_N_9 0.02558f
C571 FS_LOW_P HS_N_8 0.21311f
C572 DIV_LOW_N TERM_N_R 0.14472f
C573 VCM_LOW_OK PULLDOWN_N_R 0.09227f
C574 DIV_N HS_N_12 0.03462f
C575 PULLDOWN_N_R FS_P_WELL 2.83843f
C576 a_41005_206065# m2_42279_196800# 0
C577 HS_N_1 VDD 4.91737f
C578 PULLUP_P_GATE HS_N_4 0.08296f
C579 FS_P_BLEED_0 FS_HIGH_P 0.23079f
C580 PULLUP_P_BLEED_5 HS_N_7 0.03702f
C581 FS_LOW_N HS_N_12 0.08441f
C582 TERM_OR_N_S HS_N_5 0.02662f
C583 PULLUP_P_BLEED_3 HS_N_0 0.03489f
C584 TERM_ENABLE TERM_OR_P_B 5.36669f
C585 PULLDOWN_N_R PAD_N 4.48191f
C586 HS_N_5 HS_N_0 0.04157f
C587 DIV_ENABLE FS_P_BLEED_2 0
C588 HS_N HS_P_8 0.19016f
C589 TERM_GATE_P_BLEED_2 TERM_N_R 0.8432f
C590 DIV_N HS_N_1 0.03462f
C591 TERM_GATE_N_BLEED_0 HS_N_4 0.03489f
C592 FS_N_BLEED_3 PULLUP_N_GATE 0
C593 a_43813_189064# a_44789_189064# 2.94235f
C594 PULLDOWN_P HS_PBIAS 0.44043f
C595 TERM_OR_N_S HS_P 0.05632f
C596 PULLUP_P_BLEED_4 HS_N_8 0.0525f
C597 HS_N_2 PULLUP_P_BLEED_3 0.03489f
C598 HS_N_0 HS_P 0.16427f
C599 HS_N_1 FS_LOW_N 0.12614f
C600 TERM_ENABLE FS_N_OUT 0.47587f
C601 HS_N_0 PULLUP_P_CONTROL_S 0.05093f
C602 TERM_GATE_P TERM_OR_P_B 12.9405f
C603 HS_N_5 HS_N_2 0.00106f
C604 FS_HIGH_N TERM_N_R 0.05037f
C605 HS_N_2 HS_P 0.85293f
C606 HS_N_3 HS_N_6 0.04183f
C607 TERM_P_R PULLUP_N 0.07457f
C608 HS_P_8 PULLUP_P_OUT 0.00135f
C609 TERM_GATE_P FS_N_OUT 0.1125f
C610 PAD_P HS_P_9 1.35439f
C611 HS_N_11 VCM_LOW_OK 0.05893f
C612 HS_N_2 PULLUP_P_CONTROL_S 0.04855f
C613 HS_N_11 FS_P_WELL 2.03147f
C614 FS_P_BLEED_0 HS_PBIAS 0.08856f
C615 HS_N HS_P_5 0.39228f
C616 TERM_VCM HS_P_7 0.09615f
C617 TERM_GATE_P_BLEED_0 HS_P_6 0.02404f
C618 HS_N_7 PULLUP_N_OUT 0.05812f
C619 FS_P_BLEED_0 PULLUP_P_WELL 0
C620 PULLDOWN_P DIFF_ENABLE 0.21707f
C621 DIV_ENABLE HS_N_3 0.03089f
C622 FS_P_BLEED_3 HS_N_9 0.04642f
C623 PULLUP_N_BLEED_3 PULLDOWN_N_R 0.00237f
C624 HS_N_11 PAD_N 1.22201f
C625 FS_LOW_P HS_P_9 0.05657f
C626 FS_N_BLEED_1 PULLDOWN_N_R 0.09111f
C627 PULLUP_N_CONTROL_S PULLUP_N_GATE 1.68347f
C628 HS_P_10 TERM_N_R 0.05037f
C629 PULLUP_P_GATE PULLUP_P 5.95692f
C630 HS_P_3 PULLDOWN_N_R 0.07217f
C631 a_41005_204385# m2_42279_196800# 0
C632 HS_N_4 HS_P_6 0.0599f
C633 HS_P_7 HS_P_1 0.05962f
C634 PULLUP_P_WELL PULLUP_P_BLEED_1 0.15492f
C635 TERM_GATE_N_BLEED_0 PULLUP_P 0.05462f
C636 HS_N_8 HS_N_9 0.11968p
C637 HS_N_4 PULLUP_P 0.02473f
C638 PULLUP_P_BLEED_5 PULLDOWN_N_R 0.09196f
C639 HS_P_0 HS_N_6 0.03737f
C640 TERM_ENABLE FS_N_CONTROL_S 0.12118f
C641 VDD PULLUP_P_BLEED_3 0.44664f
C642 HS_P_10 PULLDOWN_P_R 0.07466f
C643 PAD_P ESD_RAIL 24.1165f
C644 VDD HS_N_5 6.46267f
C645 TERM_ENABLE HS_N_13 0.10332f
C646 PULLUP_P_GATE HS_N_12 0.08333f
C647 FS_N_GATE PULLUP_P 0.9856f
C648 FS_N_BLEED_2 TERM_N_R 0.05729f
C649 DIV_N PULLUP_P_BLEED_3 0.10151f
C650 FS_P_BLEED_1 FS_N_OUT 0.36323f
C651 TERM_GATE_N_BLEED_0 HS_N_12 0.03489f
C652 VDD PULLUP_P_CONTROL_S 4.743f
C653 HS_N_4 HS_N_12 0
C654 PULLUP_P_BLEED_3 FS_LOW_N 0.00876f
C655 DIV_N HS_N_5 0.03462f
C656 VDD HS_P 1.62825f
C657 FS_N_BLEED_3 PULLUP_N_WELL 0
C658 HS_N_1 PULLUP_P_GATE 0.08375f
C659 a_41005_205505# ESD_RAIL 0.53842f
C660 TERM_GATE_P HS_N_13 0.1076f
C661 HS_N HS_P_11 0.6688f
C662 HS_N_5 FS_LOW_N 0.08469f
C663 HS_P_3 HS_N_11 0.02508f
C664 a_43813_189064# a_41005_203545# 2.2693f
C665 DIV_N HS_P 0.03732f
C666 DIV_N PULLUP_P_CONTROL_S 0.06087f
C667 HS_N_1 TERM_GATE_N_BLEED_0 0.03489f
C668 HS_N_1 HS_N_4 0
C669 PULLUP_N_OUT PULLDOWN_N_R 0.08331f
C670 FS_LOW_P FS_P_GATE 0.55919f
C671 PAD_P HS_N_10 0.11949f
C672 FS_LOW_N HS_P 0.08532f
C673 PULLUP_P_BLEED_3 BYPASS_ENABLE 0.00766f
C674 HS_N_8 VCM_LOW_OK 0.05893f
C675 PULLUP_P_BLEED_5 HS_N_11 0.02434f
C676 a_41005_204945# ESD_RAIL 0.53823f
C677 HS_N_8 FS_P_WELL 1.99903f
C678 FS_N_GATE HS_N_12 0.01973f
C679 FS_P_BLEED_0 FS_P_BLEED_2 0
C680 FS_N_OUT TERM_OR_P_B 0.05082f
C681 TERM_OR_N_B HS_P 0
C682 FS_LOW_P HS_N_10 0.08505f
C683 HS_N_8 PAD_N 1.07245f
C684 HS_P_9 HS_N_9 0.06704f
C685 HS_P_11 PULLUP_P_OUT 0.05519f
C686 TERM_VCM FS_N_BLEED_4 0.04263f
C687 HS_N_6 TERM_VCM 0.17751f
C688 PULLUP_P_CONTROL_S BYPASS_ENABLE 0.00444f
C689 TERM_OR_P_NS HS_P_4 0.02846f
C690 PULLUP_N_WELL PULLUP_N_CONTROL_S 0.11761f
C691 HS_N TERM_GATE_N_BLEED_2 0.05048f
C692 DIV_ENABLE TERM_VCM 0.20793f
C693 HS_N_6 HS_P_1 0.03099f
C694 PULLUP_P_BLEED_4 HS_N_10 0.0527f
C695 HS_P_6 HS_N_12 0.05906f
C696 TERM_GATE_P_BLEED_1 TERM_GATE_P_BLEED_2 1.09058f
C697 PULLUP_P HS_N_12 0.0678f
C698 HS_N_11 PULLUP_N_OUT 0.01419f
C699 HS_N_3 FS_P_BLEED_0 0.06178f
C700 FS_N_BLEED_0 FS_N_BLEED_4 0.00763f
C701 FS_P_BLEED_1 HS_N_13 0.03472f
C702 HS_N_1 HS_P_6 0.06023f
C703 FS_N_WELL HS_N_10 0.00889f
C704 PAD_P TERM_P_R 0.63614f
C705 HS_N_1 PULLUP_P 0.02404f
C706 FS_P_CONTROL_S HS_N_6 0.03226f
C707 HS_P_9 VCM_LOW_OK 0.0458f
C708 TERM_GATE_P_BLEED_0 HS_N_5 0
C709 PULLUP_N_BLEED_5 TERM_P_R 0.11141f
C710 HS_P_3 HS_N_8 0.02404f
C711 TERM_OR_P_B HS_N_13 0.07271f
C712 FS_LOW_P TERM_P_R 0.15007f
C713 PULLUP_P_GATE PULLUP_P_BLEED_3 0.23044f
C714 TERM_ENABLE HS_P_8 0.02404f
C715 HS_P_9 PAD_N 6.47937f
C716 FS_N_CONTROL_S FS_N_OUT 0.01993f
C717 FS_P_GATE HS_N_9 1.05196f
C718 HS_N_5 PULLUP_P_GATE 0.08413f
C719 HS_N TERM_GATE_N 0.08686f
C720 TERM_OR_P_S TERM_P_R 2.01371f
C721 ESD_RAIL m2_42279_196800# 5.47988f
C722 HS_N_7 FS_P_BLEED_6 0.06178f
C723 HS_P_10 HS_P_7 0.10683f
C724 TERM_OR_N_NS HS_N_7 0.03425f
C725 TERM_GATE_N_BLEED_0 HS_N_5 0.03489f
C726 TERM_GATE_P_BLEED_0 HS_P 0.00154f
C727 TERM_GATE_N_BLEED_1 HS_N_0 0.05293f
C728 PULLUP_P_BLEED_5 HS_N_8 0.04243f
C729 PULLUP_P_BLEED_3 HS_N_4 0.03489f
C730 DIFF_ENABLE PULLUP_N 0.26007f
C731 HS_N_1 HS_N_12 0.03364f
C732 HS_N_10 HS_N_9 0.03655f
C733 PULLUP_P_GATE PULLUP_P_CONTROL_S 1.18123f
C734 PULLUP_P_GATE HS_P 0.08871f
C735 HS_N_5 HS_N_4 0.12253p
C736 TERM_GATE_P HS_P_8 0.15508f
C737 PULLUP_N_BLEED_4 PULLUP_N_GATE 0.20501f
C738 TERM_GATE_N_BLEED_0 HS_P 0.03489f
C739 HS_N_2 TERM_GATE_N_BLEED_1 0.0525f
C740 HS_N_4 PULLUP_P_CONTROL_S 0.04808f
C741 HS_N_4 HS_P 0.33321f
C742 TERM_ENABLE HS_P_5 0.02404f
C743 DIV_LOW_N HS_N_6 0.06178f
C744 HS_N TERM_N_R 0.14159f
C745 DIV_ENABLE DIV_LOW_N 9.85993f
C746 TERM_P_R FS_N_WELL 1.29698f
C747 FS_N_GATE HS_P 1.48197f
C748 PULLDOWN_P TERM_VCM 0.18094f
C749 ESD_RAIL PAD_N 22.0614f
C750 TERM_GATE_P HS_P_5 0.15599f
C751 HS_N_8 PULLUP_N_OUT 0.01067f
C752 FS_P_GATE VCM_LOW_OK 1.23568f
C753 PULLUP_P_BLEED_0 PULLDOWN_N_R 0.00171f
C754 FS_P_GATE FS_P_WELL 0.26394p
C755 PULLUP_N_BLEED_0 PULLUP_N_GATE 0.05192f
C756 HS_N PULLDOWN_P_R 0.04388f
C757 TERM_N_R PULLUP_P_OUT 0.09296f
C758 HS_P_3 HS_P_9 0.04194f
C759 FS_P_WELL HS_N_10 2.06442f
C760 VCM_LOW_OK HS_N_10 0.05893f
C761 PULLUP_P_BLEED_3 PULLUP_P 0.27184f
C762 HS_N_5 HS_P_6 0.05828f
C763 PULLDOWN_P FS_N_BLEED_0 0.07407f
C764 HS_N_5 PULLUP_P 0.0678f
C765 HS_N_10 PAD_N 1.35483f
C766 TERM_P_R HS_N_9 0.0592f
C767 FS_P_BLEED_0 TERM_VCM 0.09235f
C768 FS_P_BLEED_6 PULLDOWN_N_R 0.10124f
C769 TERM_OR_N_NS PULLDOWN_N_R 0.04764f
C770 PULLUP_P_BLEED_2 TERM_N_R 0.11444f
C771 HS_P_6 HS_P 3.46603f
C772 PULLUP_N_BLEED_6 TERM_N_R 0.06125f
C773 FS_LOW_P FS_HIGH_P 8.96232f
C774 FS_HIGH_N FS_N_BLEED_4 0.16623f
C775 FS_LOW_P DIV_LOW_P 0.12545f
C776 PULLUP_P HS_P 0.02404f
C777 PULLDOWN_N_R PULLUP_N_GATE 0.15922f
C778 PULLDOWN_P_R PULLUP_P_OUT 0.13835f
C779 PULLUP_N_BLEED_0 PULLUP_N_BLEED_1 3.40429f
C780 TERM_VCM PULLUP_P_BLEED_1 0.01882f
C781 PULLUP_P PULLUP_P_CONTROL_S 6.1629f
C782 HS_N_7 FS_P_OUT 0.52477f
C783 VDD FS_N_BLEED_3 0.5567f
C784 DIV_ENABLE FS_HIGH_N 3.66887f
C785 PAD_P HS_P_12 1.66835f
C786 TERM_ENABLE HS_P_11 0.07923f
C787 HS_P_8 TERM_OR_P_B 0.10057f
C788 PULLUP_P_BLEED_3 HS_N_12 0.03489f
C789 DIV_N TERM_GATE_N_BLEED_1 0
C790 HS_N_6 HS_P_10 0.03097f
C791 PAD_P HS_P_13 1.35247f
C792 HS_N_5 HS_N_12 0
C793 FS_LOW_P HS_P_12 0.17418f
C794 VDD HS_P_4 4.77123f
C795 TERM_GATE_N_BLEED_1 FS_LOW_N 0.0839f
C796 FS_P_BLEED_0 FS_P_CONTROL_S 0.00276f
C797 PULLUP_N_OUT HS_P_9 0.07928f
C798 HS_N_1 PULLUP_P_BLEED_3 0.03489f
C799 FS_HIGH_P PULLUP_P_BLEED_4 0.03577f
C800 TERM_GATE_P HS_P_11 0.1736f
C801 HS_P HS_N_12 0.78589f
C802 FS_N_BLEED_3 FS_LOW_N 0
C803 PULLUP_P_CONTROL_S HS_N_12 0.04885f
C804 FS_LOW_P HS_P_13 0.04601f
C805 HS_N_1 HS_N_5 0
C806 PULLDOWN_N_R PULLUP_N_BLEED_1 0.07928f
C807 PULLDOWN_N HS_P 0.03743f
C808 FS_LOW_P HS_PBIAS 0.34356f
C809 PAD_P HS_P_2 1.20139f
C810 TERM_P_R VCM_LOW_OK 0.39366f
C811 FS_P_BLEED_6 HS_N_11 0.06178f
C812 TERM_P_R FS_P_WELL 1.46056f
C813 TERM_OR_N_NS HS_N_11 0.03425f
C814 DIV_LOW_N PULLDOWN_P 0.08856f
C815 FS_LOW_P PULLUP_P_WELL 0.27223f
C816 FS_HIGH_P FS_N_WELL 1.65568f
C817 HS_P_5 TERM_OR_P_B 0.10156f
C818 HS_N_7 TERM_OR_P_NS 0.00491f
C819 HS_N_1 PULLUP_P_CONTROL_S 0.05002f
C820 HS_P_3 HS_N_10 0.02545f
C821 FS_N_BLEED_2 FS_N_BLEED_4 0.00855f
C822 HS_N_1 HS_P 0.13598f
C823 DIV_ENABLE RX_P 0.88297f
C824 PULLUP_N_BLEED_0 PULLUP_N_WELL 5.00789f
C825 FS_LOW_P HS_P_2 0.04618f
C826 PULLDOWN_N_R DIV_P 0.01299f
C827 VDD PULLUP_N_CONTROL_S 0.68736f
C828 TERM_ENABLE TERM_GATE_N_BLEED_2 0.07928f
C829 PULLUP_P_BLEED_5 HS_N_10 0.02441f
C830 FS_N_OUT HS_P_5 0.06167f
C831 PULLUP_P_BLEED_4 HS_PBIAS 0.07928f
C832 FS_N_BLEED_5 FS_N_BLEED_4 0.79478f
C833 PULLUP_N_BLEED_5 DIFF_ENABLE 0
C834 PULLUP_P_BLEED_4 PULLUP_P_WELL 0
C835 FS_HIGH_P HS_N_9 0.02404f
C836 FS_LOW_P DIFF_ENABLE 0.27413f
C837 FS_P_OUT PULLDOWN_N_R 0.68986f
C838 DIV_ENABLE FS_N_BLEED_5 0
C839 HS_PBIAS FS_N_WELL 3.33611f
C840 PULLUP_N_WELL PULLDOWN_N_R 0.304f
C841 a_41684_220611# ESD_RAIL 1.21921p
C842 FS_P_GATE PULLUP_N_OUT 1.30807f
C843 HS_N HS_P_7 0.15132f
C844 PULLDOWN_P FS_HIGH_N 0.03743f
C845 HS_P_12 HS_N_9 0.06578f
C846 TERM_ENABLE TERM_GATE_N 10.756f
C847 FS_P_BLEED_4 HS_N_9 0.06295f
C848 HS_N FS_P_BLEED_5 0.08043f
C849 FS_P_BLEED_6 FS_P_BLEED_3 0.12236f
C850 HS_P_13 HS_N_9 0.05493f
C851 HS_P_3 TERM_P_R 0.12136f
C852 HS_P_11 TERM_OR_P_B 0.11938f
C853 TERM_GATE_N_BLEED_0 TERM_GATE_N_BLEED_1 7.21575f
C854 HS_N_5 PULLUP_P_BLEED_3 0.03489f
C855 TERM_OR_N_S HS_N_7 0.02895f
C856 HS_PBIAS HS_N_9 1.96438f
C857 a_43813_189064# ESD_RAIL 4.89902f
C858 FS_LOW_P FS_P_BLEED_2 0.0781f
C859 TERM_OR_P_NS PULLDOWN_N_R 0.04591f
C860 TERM_GATE_P_BLEED_0 HS_P_4 0.02451f
C861 HS_N_0 HS_N_7 0.07359f
C862 PULLUP_P_WELL HS_N_9 0.14182f
C863 TERM_GATE_N_BLEED_1 HS_N_4 0.0525f
C864 HS_N_8 FS_P_BLEED_6 0.06178f
C865 TERM_OR_N_NS HS_N_8 0.03425f
C866 HS_N_11 FS_P_OUT 0.43976f
C867 FS_HIGH_P VCM_LOW_OK 0.02051f
C868 TERM_GATE_P_BLEED_1 PULLUP_P_OUT 0.14929f
C869 FS_HIGH_P FS_P_WELL 6.72442f
C870 TERM_ENABLE TERM_N_R 0.48319f
C871 PULLUP_P_BLEED_3 HS_P 0.03489f
C872 HS_P_2 HS_N_9 0.03089f
C873 FS_P_BLEED_5 PULLUP_P_OUT 0.05047f
C874 HS_P_5 HS_N_13 0.03489f
C875 HS_N_5 HS_P 0.87187f
C876 HS_N_5 PULLUP_P_CONTROL_S 0.04808f
C877 HS_N_2 HS_N_7 0.02926f
C878 HS_N_4 HS_P_4 0
C879 PULLDOWN_P FS_N_BLEED_2 0.08856f
C880 TERM_GATE_P TERM_N_R 1.39719f
C881 PAD_P HS_N_3 0.09104f
C882 VCM_LOW_OK HS_P_12 0.03489f
C883 FS_N_BLEED_3 FS_N_GATE 0.19336f
C884 HS_P_12 FS_P_WELL 0.00134f
C885 PULLUP_P_CONTROL_S HS_P 0.04808f
C886 TERM_ENABLE PULLDOWN_P_R 0.08114f
C887 HS_P_12 PAD_N 0.22324f
C888 HS_N_3 FS_LOW_P 0.08505f
C889 PULLUP_N_OUT TERM_P_R 0.26239f
C890 VCM_LOW_OK HS_P_13 0.03489f
C891 HS_P_13 FS_P_WELL 0.19945f
C892 HS_PBIAS VCM_LOW_OK 0.42204f
C893 HS_PBIAS FS_P_WELL 3.47125f
C894 TERM_GATE_P PULLDOWN_P_R 0.30143f
C895 HS_P PULLUP_N_BLEED_2 0.00212f
C896 HS_P_13 PAD_N 0.16938f
C897 PULLUP_P_WELL VCM_LOW_OK 0.26131f
C898 TERM_GATE_N_BLEED_1 PULLUP_P 0.09196f
C899 HS_N FS_N_BLEED_4 0.06151f
C900 HS_P_2 VCM_LOW_OK 0.03489f
C901 PAD_P HS_P_0 1.64024f
C902 HS_N HS_N_6 7.99416f
C903 HS_N_3 PULLUP_P_BLEED_4 0.0525f
C904 FS_N_BLEED_3 PULLUP_P 0.10124f
C905 TERM_OR_N_S PULLDOWN_N_R 0.08196f
C906 HS_N_0 PULLDOWN_N_R 0.06832f
C907 HS_P_2 PAD_N 2.43754f
C908 DIV_ENABLE HS_N 0.05802f
C909 FS_HIGH_P FS_N_BLEED_1 0
C910 HS_P_6 HS_P_4 0.06956f
C911 FS_LOW_P HS_P_0 0.0932f
C912 VDD HS_N_7 5.51673f
C913 FS_P_BLEED_1 TERM_N_R 0.06105f
C914 HS_N_8 FS_P_OUT 0.43367f
C915 PULLDOWN_P_R PULLUP_P_BLEED_6 0.19409f
C916 VDD PULLUP_N_BLEED_4 0.0157f
C917 TERM_GATE_N_BLEED_1 HS_N_12 0.05263f
C918 HS_N_6 PULLUP_P_OUT 0.03489f
C919 HS_N_2 PULLDOWN_N_R 0.02404f
C920 DIV_N HS_N_7 0.03462f
C921 a_53878_203545# ESD_RAIL 0.56772f
C922 HS_P_3 HS_P_12 0.02899f
C923 a_53878_205225# ESD_RAIL 0.53916f
C924 TERM_GATE_N FS_N_OUT 0.05082f
C925 HS_N_7 FS_LOW_N 0.08486f
C926 FS_P_BLEED_1 PULLDOWN_P_R 0.05445f
C927 TERM_N_R TERM_OR_P_B 1.12426f
C928 HS_N_1 TERM_GATE_N_BLEED_1 0.05286f
C929 HS_P_8 HS_P_5 0.00106f
C930 HS_P_3 HS_P_13 0.2651f
C931 PULLUP_P PULLUP_N_CONTROL_S 0.09193f
C932 FS_N_BLEED_1 HS_PBIAS 0.08856f
C933 TERM_GATE_N_BLEED_2 HS_N_13 0.02404f
C934 HS_P_3 HS_PBIAS 6.23881f
C935 HS_N_3 HS_N_9 0.03256f
C936 VDD PULLUP_N_BLEED_0 0
C937 TERM_OR_N_S HS_N_11 0.02508f
C938 DIV_ENABLE PULLUP_N_BLEED_6 0.03269f
C939 HS_N_0 HS_N_11 0.0421f
C940 HS_N_8 TERM_OR_P_NS 0.00704f
C941 FS_N_OUT TERM_N_R 0.38856f
C942 PULLUP_P_BLEED_5 HS_PBIAS 0.17636f
C943 FS_P_BLEED_2 FS_P_WELL 0.00213f
C944 FS_P_GATE FS_P_BLEED_6 6.82321f
C945 PULLDOWN_P_R TERM_OR_P_B 0.17949f
C946 FS_HIGH_P PULLUP_N_OUT 0.05082f
C947 PAD_P TERM_VCM 0.0037f
C948 HS_P_3 HS_P_2 34.3283f
C949 FS_LOW_N PULLUP_N_BLEED_0 0.08389f
C950 HS_N_2 HS_N_11 0.0256f
C951 FS_P_BLEED_6 HS_N_10 0.06178f
C952 TERM_OR_N_NS HS_N_10 0.03425f
C953 PULLUP_N_BLEED_5 TERM_VCM 0.13759f
C954 FS_LOW_P TERM_VCM 0.24801f
C955 PAD_P HS_P_1 1.23389f
C956 TERM_VCM TERM_OR_P_S 0.05962f
C957 TERM_ENABLE HS_P_7 0.02404f
C958 HS_P_0 HS_N_9 0.03791f
C959 PULLUP_N_OUT HS_P_12 0.03006f
C960 VDD PULLDOWN_N_R 2.95843f
C961 FS_LOW_P HS_P_1 0.11262f
C962 PULLUP_N_OUT FS_P_BLEED_4 0
C963 TERM_ENABLE TERM_GATE_P_BLEED_1 0.10319f
C964 PULLUP_N_OUT HS_P_13 0.02868f
C965 DIV_N PULLDOWN_N_R 0.0471f
C966 TERM_ENABLE FS_P_BLEED_5 0.00492f
C967 TERM_GATE_N HS_N_13 0.04808f
C968 HS_N_3 VCM_LOW_OK 0.05893f
C969 FS_LOW_P FS_N_BLEED_0 0.79203f
C970 HS_N_3 FS_P_WELL 1.96364f
C971 TERM_GATE_P HS_P_7 0.15508f
C972 PULLUP_N_OUT HS_PBIAS 0.76895f
C973 FS_LOW_N PULLDOWN_N_R 0.05849f
C974 HS_P_11 HS_P_8 0.00792f
C975 HS_N_3 PAD_N 1.66755f
C976 TERM_GATE_P_BLEED_0 HS_N_7 0
C977 PULLUP_N_OUT PULLUP_P_WELL 0.6012f
C978 TERM_GATE_P TERM_GATE_P_BLEED_1 0.37616f
C979 FS_N_CONTROL_S TERM_N_R 0.12536f
C980 HS_P_2 PULLUP_N_OUT 0.07964f
C981 TERM_OR_N_B PULLDOWN_N_R 0.04207f
C982 HS_P_9 TERM_OR_P_NS 0.03937f
C983 HS_N_0 FS_P_BLEED_3 0.02973f
C984 TERM_VCM FS_N_WELL 1.58767f
C985 PULLUP_P_GATE HS_N_7 0.08496f
C986 FS_P_BLEED_0 HS_N 0.07763f
C987 TERM_GATE_N_BLEED_0 HS_N_7 0.03489f
C988 HS_N_5 TERM_GATE_N_BLEED_1 0.0525f
C989 TERM_N_R HS_N_13 0.10989f
C990 TERM_OR_N_S HS_N_8 0.03108f
C991 FS_P_BLEED_6 TERM_P_R 0.04565f
C992 TERM_OR_N_NS TERM_P_R 0.21356f
C993 HS_N_7 HS_N_4 0.07687f
C994 VDD HS_N_11 6.59331f
C995 HS_N_0 HS_N_8 0.04157f
C996 TERM_P_R PULLUP_N_GATE 0.15782f
C997 HS_P_0 VCM_LOW_OK 0.04122f
C998 HS_N_2 FS_P_BLEED_3 0.02846f
C999 PULLDOWN_P PULLUP_N_BLEED_6 0.04122f
C1000 TERM_GATE_N_BLEED_1 HS_P 0.0525f
C1001 DIV_N HS_N_11 0.03462f
C1002 FS_P_GATE FS_P_OUT 0.13406p
C1003 FS_N_BLEED_0 FS_N_WELL 2.72415f
C1004 HS_P_11 HS_P_5 0.03881f
C1005 FS_P_BLEED_0 PULLUP_P_OUT 0.11038f
C1006 HS_P_0 PAD_N 0.38312f
C1007 HS_N_5 HS_P_4 0.13307f
C1008 FS_N_BLEED_3 HS_P 0.08856f
C1009 PULLDOWN_P_R HS_N_13 0.02404f
C1010 HS_N_2 HS_N_8 0.00333f
C1011 FS_LOW_N HS_N_11 0.08441f
C1012 TERM_VCM HS_N_9 0.14022f
C1013 FS_P_OUT HS_N_10 0.44249f
C1014 HS_P HS_P_4 1.7567f
C1015 DIV_LOW_N FS_LOW_P 0.08856f
C1016 HS_P_1 HS_N_9 0.0312f
C1017 HS_N_3 HS_P_3 0.03733f
C1018 TERM_ENABLE FS_N_BLEED_4 0.06151f
C1019 HS_N_6 TERM_ENABLE 0.10332f
C1020 HS_P_7 TERM_OR_P_B 0.10117f
C1021 HS_N_3 PULLUP_P_BLEED_5 0.02807f
C1022 FS_P_CONTROL_S HS_N_9 0.03242f
C1023 DIV_ENABLE TERM_ENABLE 0.05768f
C1024 HS_N_7 HS_P_6 0.02536f
C1025 TERM_GATE_P_BLEED_0 PULLDOWN_N_R 0.0553f
C1026 TERM_P_R DIV_P 0.02242f
C1027 PULLUP_P_BLEED_2 PULLUP_P_BLEED_1 2.37421f
C1028 TERM_GATE_P_BLEED_1 TERM_OR_P_B 0.00371f
C1029 HS_N_7 PULLUP_P 0.07466f
C1030 PULLUP_P_GATE PULLDOWN_N_R 0.23555f
C1031 TERM_GATE_P HS_N_6 0.11785f
C1032 PULLUP_N_BLEED_4 PULLUP_P 0.10721f
C1033 TERM_GATE_N_BLEED_0 PULLDOWN_N_R 0.04828f
C1034 DIV_ENABLE TERM_GATE_P 0.00432f
C1035 TERM_VCM VCM_LOW_OK 0.10491p
C1036 TERM_VCM FS_P_WELL 1.40942f
C1037 HS_N_4 PULLDOWN_N_R 0.06159f
C1038 HS_P_3 HS_P_0 0.03772f
C1039 FS_LOW_P FS_HIGH_N 0.11423f
C1040 VDD HS_N_8 4.98108f
C1041 TERM_VCM PAD_N 0.001f
C1042 TERM_P_R FS_P_OUT 0.43231f
C1043 PAD_P HS_P_10 1.26307f
C1044 FS_P_BLEED_5 FS_N_OUT 0.05624f
C1045 VCM_LOW_OK HS_P_1 0.03489f
C1046 FS_HIGH_P TERM_OR_N_NS 0.00369f
C1047 HS_N_7 HS_N_12 0.02955f
C1048 FS_N_GATE PULLDOWN_N_R 1.16406f
C1049 FS_HIGH_P PULLUP_N_GATE 0.01763f
C1050 DIV_N HS_N_8 0.03462f
C1051 TERM_P_R PULLUP_N_WELL 0.29516f
C1052 HS_N_3 PULLUP_N_OUT 0.00232f
C1053 FS_LOW_P HS_P_10 0.05509f
C1054 HS_P_1 PAD_N 0.56708f
C1055 HS_N_8 FS_LOW_N 0.1267f
C1056 HS_N_6 PULLUP_P_BLEED_6 0
C1057 DIV_LOW_N HS_N_9 0.06178f
C1058 HS_N_1 HS_N_7 0.03096f
C1059 FS_P_CONTROL_S FS_P_WELL 0.18587f
C1060 PULLUP_P_WELL PULLUP_P_BLEED_0 1.08596f
C1061 PAD_P RX_P 8.52519f
C1062 HS_N_8 TERM_OR_N_B 0
C1063 PULLUP_P_GATE HS_N_11 0.08345f
C1064 FS_P_BLEED_6 FS_P_BLEED_4 0.12309f
C1065 TERM_GATE_N_BLEED_0 HS_N_11 0.03489f
C1066 PULLDOWN_P_R HS_P_8 0.08554f
C1067 FS_P_BLEED_1 HS_N_6 0.03472f
C1068 HS_N_4 HS_N_11 0
C1069 TERM_P_R TERM_OR_P_NS 0.22589f
C1070 FS_HIGH_N FS_N_WELL 2.50709f
C1071 FS_P_BLEED_6 HS_PBIAS 0.08856f
C1072 TERM_OR_N_NS HS_PBIAS 0.04764f
C1073 DIV_ENABLE FS_P_BLEED_1 0.01375f
C1074 HS_P_0 PULLUP_N_OUT 0.09237f
C1075 PULLDOWN_N_R HS_P_6 0.02414f
C1076 FS_LOW_P FS_N_BLEED_2 0.14463f
C1077 HS_N_0 FS_P_GATE 1.02982f
C1078 PULLUP_P PULLDOWN_N_R 0.04377f
C1079 HS_PBIAS PULLUP_N_GATE 0.14584f
C1080 FS_P_BLEED_6 PULLUP_P_WELL 0.01133f
C1081 TERM_OR_N_S HS_N_10 0.02545f
C1082 HS_N_0 HS_N_10 2.19255f
C1083 FS_N_GATE HS_N_11 0.00893f
C1084 HS_P_3 TERM_VCM 0.12019f
C1085 PULLDOWN_P TERM_ENABLE 0.05932f
C1086 VDD HS_P_9 6.02581f
C1087 a_53878_205225# a_53878_204665# 0.0346f
C1088 HS_N_2 FS_P_GATE 1.03585f
C1089 DIV_LOW_P DIV_P 0.50398f
C1090 HS_N_6 TERM_OR_P_B 0.07211f
C1091 FS_P_BLEED_5 HS_N_13 0.06178f
C1092 DIV_ENABLE TERM_OR_P_B 0
C1093 FS_LOW_P FS_N_BLEED_5 0.12388f
C1094 PULLDOWN_P_R HS_P_5 0.02404f
C1095 HS_N_2 HS_N_10 0.03509f
C1096 HS_P_3 HS_P_1 0.06154f
C1097 PULLUP_N_BLEED_6 PULLUP_N 0.17333f
C1098 PULLDOWN_N_R HS_N_12 0.06832f
C1099 FS_N_BLEED_1 FS_N_BLEED_0 4.78029f
C1100 DIFF_ENABLE PULLUP_N_GATE 0.07144f
C1101 HS_PBIAS PULLUP_N_BLEED_1 0.17672f
C1102 FS_HIGH_P FS_P_OUT 0.13265f
C1103 PULLDOWN_N_R PULLDOWN_N 2.99559f
C1104 HS_P_12 DIV_P 0.03388f
C1105 a_41005_203825# m2_42279_196800# 0
C1106 FS_P_BLEED_0 TERM_ENABLE 0.11038f
C1107 DIV_LOW_P FS_P_OUT 0.13605f
C1108 HS_P_10 HS_N_9 0.03109f
C1109 DIV_ENABLE FS_N_OUT 0.15376f
C1110 VCM_LOW_OK TERM_GATE_P_BLEED_2 0.01429f
C1111 PULLUP_P_GATE FS_P_BLEED_3 0
C1112 HS_N_11 HS_P_6 0.05932f
C1113 FS_N_BLEED_2 FS_N_WELL 0.35588f
C1114 HS_N_11 PULLUP_P 0.02473f
C1115 FS_HIGH_P PULLUP_N_WELL 0.30751f
C1116 TERM_GATE_P_BLEED_0 HS_N_8 0
C1117 HS_N_1 PULLDOWN_N_R 0.02404f
C1118 HS_N_4 FS_P_BLEED_3 0.03227f
C1119 TERM_ENABLE PULLUP_P_BLEED_1 0.07608f
C1120 PULLUP_P_GATE HS_N_8 0.08595f
C1121 PULLUP_P_BLEED_3 HS_N_7 0.03489f
C1122 PULLUP_N_OUT TERM_VCM 0.50835f
C1123 TERM_GATE_N_BLEED_0 HS_N_8 0.03489f
C1124 FS_P_OUT HS_P_12 0.10923f
C1125 HS_P_11 TERM_N_R 0.05722f
C1126 TERM_OR_N_S TERM_P_R 0.30551f
C1127 HS_N_5 HS_N_7 0.07689f
C1128 PULLDOWN_P PULLUP_P_BLEED_6 0.09848f
C1129 HS_N_0 TERM_P_R 0.10318f
C1130 HS_N_4 HS_N_8 0.04079f
C1131 FS_P_OUT HS_P_13 0.1275f
C1132 TERM_GATE_N_BLEED_2 TERM_GATE_N 0.42751f
C1133 VDD FS_P_GATE 26.6621f
C1134 FS_P_BLEED_6 FS_P_BLEED_2 0.06814f
C1135 HS_N_7 PULLUP_P_CONTROL_S 0.04808f
C1136 PULLUP_N_OUT HS_P_1 0.05947f
C1137 HS_N_7 HS_P 0.33704f
C1138 HS_N_11 HS_N_12 0.1373p
C1139 HS_PBIAS FS_P_OUT 0.96844f
C1140 HS_P_11 PULLDOWN_P_R 0.07466f
C1141 VDD HS_N_10 6.378f
C1142 HS_N_2 TERM_P_R 0.0594f
C1143 DIV_N FS_P_GATE 0.09711f
C1144 FS_N_GATE HS_N_8 0.00226f
C1145 PULLUP_N_OUT FS_N_BLEED_0 0
C1146 HS_PBIAS PULLUP_N_WELL 0.42834f
C1147 HS_P_10 VCM_LOW_OK 0.09044f
C1148 HS_N_1 HS_N_11 0.03414f
C1149 TERM_GATE_N_BLEED_2 TERM_N_R 0.12212f
C1150 HS_N_6 HS_N_13 0.08101f
C1151 DIV_N HS_N_10 0.03462f
C1152 PULLUP_N_BLEED_4 PULLUP_N_BLEED_2 0.00234f
C1153 HS_P_10 PAD_N 0.42477f
C1154 TERM_OR_P_NS HS_P_12 0.03931f
C1155 HS_P_7 HS_P_8 30.9838f
C1156 FS_LOW_N HS_N_10 0.08441f
C1157 DIV_ENABLE HS_N_13 0.03089f
C1158 TERM_GATE_P_BLEED_0 HS_P_9 0.03888f
C1159 FS_P_BLEED_0 FS_P_BLEED_1 8.76361f
C1160 TERM_OR_P_NS HS_P_13 0.02895f
C1161 PULLUP_N_BLEED_0 HS_P 0.07928f
C1162 HS_N_3 FS_P_BLEED_6 0.06178f
C1163 HS_N_3 TERM_OR_N_NS 0.03425f
C1164 PAD_P HS_N 1.23865f
C1165 HS_N_8 HS_P_6 0.04808f
C1166 HS_N_8 PULLUP_P 0.02404f
C1167 RX_P PAD_N 1.67336f
C1168 PULLUP_P_BLEED_3 PULLDOWN_N_R 0.05462f
C1169 PULLDOWN_P FS_N_OUT 0.54091f
C1170 FS_LOW_P HS_N 0.10015f
C1171 HS_P_2 TERM_OR_P_NS 0.02846f
C1172 HS_N_5 PULLDOWN_N_R 0.06832f
C1173 PULLUP_N_BLEED_0 PULLUP_N_BLEED_2 0.00326f
C1174 HS_P_7 HS_P_5 0.03078f
C1175 FS_N_BLEED_1 FS_HIGH_N 0.01132f
C1176 FS_P_BLEED_3 HS_N_12 0.02888f
C1177 DIV_LOW_N PULLUP_N_OUT 0.10124f
C1178 PAD_P PULLUP_P_OUT 0.43807f
C1179 PULLDOWN_N_R HS_P 0.08383f
C1180 VDD TERM_P_R 6.53315f
C1181 TERM_GATE_N TERM_N_R 26.1022f
C1182 PULLUP_P_CONTROL_S PULLDOWN_N_R 0.08753f
C1183 FS_HIGH_P HS_N_0 0.02438f
C1184 HS_N_0 DIV_LOW_P 0.00585f
C1185 DIV_N TERM_P_R 0
C1186 HS_N_1 FS_P_BLEED_3 0.02938f
C1187 HS_N_8 HS_N_12 0.03497f
C1188 FS_P_BLEED_0 FS_N_OUT 0.28479f
C1189 HS_P_3 HS_P_10 0.02866f
C1190 FS_LOW_P PULLUP_P_OUT 0.17673f
C1191 HS_N PULLUP_P_BLEED_4 0.10264f
C1192 TERM_ENABLE PULLUP_N 0.01513f
C1193 FS_P_OUT FS_P_BLEED_2 0
C1194 FS_LOW_N TERM_P_R 0.03634f
C1195 PULLDOWN_N_R PULLUP_N_BLEED_2 0.05146f
C1196 TERM_OR_P_S PULLUP_P_OUT 0.00441f
C1197 FS_HIGH_P HS_N_2 0.02404f
C1198 HS_N_2 DIV_LOW_P 0
C1199 HS_N_0 HS_P_12 0.07547f
C1200 TERM_P_R TERM_OR_N_B 0.37734f
C1201 PULLUP_P_BLEED_3 HS_N_11 0.03489f
C1202 HS_N FS_N_WELL 4.96692f
C1203 HS_N_3 DIV_P 0.03388f
C1204 PULLUP_N_BLEED_5 PULLUP_N_BLEED_6 4.58267f
C1205 HS_N_0 FS_P_BLEED_4 0.06178f
C1206 PULLDOWN_P FS_N_CONTROL_S 0.09439f
C1207 FS_LOW_P PULLUP_N_BLEED_6 0.06116f
C1208 HS_P_9 HS_P_6 0.00106f
C1209 HS_N_5 HS_N_11 0
C1210 PULLUP_P_GATE FS_P_GATE 0.53486f
C1211 HS_N_0 HS_P_13 0.02661f
C1212 TERM_OR_N_S HS_PBIAS 0.12657f
C1213 FS_N_BLEED_2 FS_N_BLEED_1 6.33216f
C1214 HS_N_11 HS_P 0.77257f
C1215 HS_N_0 HS_PBIAS 7.78201f
C1216 HS_N_2 HS_P_12 0.06578f
C1217 PULLDOWN_P HS_N_13 0.04428f
C1218 HS_N_4 FS_P_GATE 1.03504f
C1219 PULLUP_P_GATE HS_N_10 0.08357f
C1220 PULLUP_N_OUT FS_HIGH_N 0.04377f
C1221 HS_N_2 FS_P_BLEED_4 0.06178f
C1222 HS_N_11 PULLUP_P_CONTROL_S 0.04911f
C1223 HS_N_3 FS_P_OUT 0.48792f
C1224 TERM_GATE_N_BLEED_0 HS_N_10 0.03489f
C1225 HS_N_0 PULLUP_P_WELL 0.24542f
C1226 HS_N_2 HS_P_13 0.07762f
C1227 HS_P_11 HS_P_7 0.0963f
C1228 HS_N_4 HS_N_10 0
C1229 HS_N HS_N_9 5.97147f
C1230 HS_P_10 PULLUP_N_OUT 0.08961f
C1231 HS_N_2 HS_PBIAS 1.31428f
C1232 PULLUP_P_BLEED_4 PULLUP_P_BLEED_2 0
C1233 FS_P_BLEED_6 TERM_VCM 0.01859f
C1234 TERM_OR_N_NS TERM_VCM 0.03439f
C1235 HS_N_2 PULLUP_P_WELL 0.11473f
C1236 TERM_VCM PULLUP_N_GATE 0.19338f
C1237 FS_N_GATE HS_N_10 0.00893f
C1238 FS_P_BLEED_0 HS_N_13 0.06178f
C1239 HS_P_2 HS_N_2 0.06704f
C1240 HS_N_6 HS_P_5 0.1437f
C1241 VDD FS_HIGH_P 0.65065f
C1242 PULLUP_P_OUT HS_N_9 0.03516f
C1243 HS_P_0 FS_P_OUT 0.09146f
C1244 HS_N_3 TERM_OR_P_NS 0.00153f
C1245 DIV_ENABLE HS_P_5 0.00252f
C1246 DIV_N FS_HIGH_P 8.67054f
C1247 DIV_N DIV_LOW_P 0.89345f
C1248 TERM_GATE_P_BLEED_0 TERM_P_R 0.00257f
C1249 HS_N_5 FS_P_BLEED_3 0.03351f
C1250 PULLUP_N_OUT FS_N_BLEED_2 0.10124f
C1251 FS_HIGH_P FS_LOW_N 93.2133f
C1252 PULLUP_P_BLEED_3 HS_N_8 0.03489f
C1253 TERM_GATE_N_BLEED_1 HS_N_7 0.0525f
C1254 PULLUP_P_GATE TERM_P_R 0.15811f
C1255 VDD HS_P_12 4.78775f
C1256 HS_P_6 HS_N_10 0.0597f
C1257 HS_N VCM_LOW_OK 0.07865f
C1258 HS_N_5 HS_N_8 0.04101f
C1259 HS_N FS_P_WELL 41.6575f
C1260 TERM_GATE_N_BLEED_0 TERM_P_R 0.04766f
C1261 FS_P_BLEED_3 HS_P 0.0834f
C1262 PULLUP_P HS_N_10 0.02404f
C1263 HS_N_4 TERM_P_R 0.05893f
C1264 DIV_N HS_P_12 0.01246f
C1265 VDD HS_P_13 6.64318f
C1266 FS_HIGH_P BYPASS_ENABLE 0
C1267 VDD HS_PBIAS 83.74921f
C1268 DIV_LOW_P BYPASS_ENABLE 0
C1269 HS_N PAD_N 35.6371f
C1270 HS_N_8 HS_P 0.55444f
C1271 HS_P_0 TERM_OR_P_NS 0.07621f
C1272 HS_N_0 FS_P_BLEED_2 0
C1273 TERM_VCM DIV_P 0.13218f
C1274 HS_N_8 PULLUP_P_CONTROL_S 0.04808f
C1275 VDD PULLUP_P_WELL 30.3758f
C1276 FS_P_GATE HS_N_12 1.03841f
C1277 FS_N_GATE TERM_P_R 0.72109f
C1278 PULLUP_P_OUT FS_P_WELL 3.0456f
C1279 VDD HS_P_2 5.70329f
C1280 DIV_N HS_PBIAS 0.14108f
C1281 VCM_LOW_OK PULLUP_P_OUT 0.13743f
C1282 DIV_N PULLUP_P_WELL 0.08038f
C1283 FS_LOW_N HS_PBIAS 0.39667f
C1284 HS_N_12 HS_N_10 0.07075f
C1285 HS_N_1 FS_P_GATE 1.0435f
C1286 HS_N_6 HS_P_11 0.03089f
C1287 PULLUP_P_OUT PAD_N 0.20908f
C1288 TERM_VCM FS_P_OUT 0.38638f
C1289 HS_PBIAS TERM_OR_N_B 0.01781f
C1290 VDD DIFF_ENABLE 0.45362f
C1291 PULLUP_N_BLEED_5 TERM_ENABLE 0.11535f
C1292 HS_N_1 HS_N_10 0.12635p
C1293 TERM_VCM PULLUP_N_WELL 0.36125f
C1294 PULLUP_P_BLEED_2 VCM_LOW_OK 0.15227f
C1295 FS_LOW_P TERM_ENABLE 0.13548f
C1296 HS_N_3 TERM_OR_N_S 0.02557f
C1297 HS_N_3 HS_N_0 0.08089f
C1298 TERM_P_R HS_P_6 0.08356f
C1299 PULLUP_P_WELL BYPASS_ENABLE 0.00823f
C1300 TERM_ENABLE TERM_OR_P_S 0.23041f
C1301 TERM_GATE_P_BLEED_1 TERM_N_R 0.23767f
C1302 TERM_P_R PULLUP_P 0.1121f
C1303 TERM_GATE_N_BLEED_1 PULLDOWN_N_R 0.07928f
C1304 FS_LOW_N DIFF_ENABLE 0.20718f
C1305 HS_N FS_N_BLEED_1 0.11535f
C1306 HS_P_3 HS_N 0.27803f
C1307 FS_LOW_P TERM_GATE_P 0.15357f
C1308 HS_N_3 HS_N_2 0.12365p
C1309 FS_N_BLEED_3 PULLDOWN_N_R 0.08856f
C1310 FS_P_CONTROL_S FS_P_OUT 0
C1311 HS_P_9 HS_P 6.36218f
C1312 HS_N_6 TERM_GATE_N_BLEED_2 0.03334f
C1313 FS_N_BLEED_0 PULLUP_N_WELL 0
C1314 HS_N PULLUP_P_BLEED_5 0.05048f
C1315 TERM_VCM TERM_OR_P_NS 0.0013f
C1316 FS_HIGH_P PULLUP_P_GATE 0.03189f
C1317 DIFF_ENABLE BYPASS_ENABLE 5.18795f
C1318 FS_HIGH_P TERM_GATE_N_BLEED_0 0.15807f
C1319 PULLDOWN_N_R HS_P_4 0.07217f
C1320 PULLDOWN_P_R HS_P_7 0.02411f
C1321 PULLDOWN_P_R TERM_GATE_P_BLEED_1 0.01413f
C1322 FS_HIGH_P HS_N_4 0.02404f
C1323 HS_P_0 HS_N_0 0.04061f
C1324 TERM_GATE_P_BLEED_0 HS_P_12 0.03636f
C1325 TERM_OR_P_NS HS_P_1 0.04312f
C1326 PULLDOWN_P_R FS_P_BLEED_5 0.11255f
C1327 TERM_P_R HS_N_12 0.0597f
C1328 TERM_ENABLE FS_N_WELL 2.50751f
C1329 TERM_P_R PULLDOWN_N 0.05332f
C1330 HS_P_3 PULLUP_P_OUT 0.05276f
C1331 FS_HIGH_N PULLUP_N_GATE 0.01195f
C1332 TERM_GATE_P_BLEED_0 HS_P_13 0.0256f
C1333 DIV_N FS_P_BLEED_2 0
C1334 PULLUP_P_GATE FS_P_BLEED_4 0
C1335 PULLUP_N_BLEED_6 PULLUP_N_BLEED_3 0.0078f
C1336 HS_P_0 HS_N_2 0.03722f
C1337 FS_HIGH_P FS_N_GATE 0.07498f
C1338 HS_N_1 TERM_P_R 0.06087f
C1339 TERM_GATE_N_BLEED_1 HS_N_11 0.05266f
C1340 HS_N_4 HS_P_12 0.07181f
C1341 HS_N_4 FS_P_BLEED_4 0.06178f
C1342 PULLUP_P_GATE HS_PBIAS 0.17404f
C1343 HS_N PULLUP_N_OUT 0.10855f
C1344 FS_LOW_P FS_P_BLEED_1 0.07139f
C1345 TERM_GATE_P_BLEED_0 HS_P_2 0.02483f
C1346 HS_N_6 TERM_GATE_N 0.04962f
C1347 HS_N_4 HS_P_13 0.02957f
C1348 TERM_GATE_N_BLEED_0 HS_PBIAS 0.04828f
C1349 HS_N_5 FS_P_GATE 1.04072f
C1350 TERM_ENABLE HS_N_9 0.04808f
C1351 PULLUP_P_GATE PULLUP_P_WELL 35.6995f
C1352 a_44789_189064# a_41005_203545# 0.02879f
C1353 HS_N_4 HS_PBIAS 2.61651f
C1354 PULLUP_P_BLEED_3 HS_N_10 0.03489f
C1355 HS_N_3 VDD 5.65374f
C1356 DIV_ENABLE TERM_GATE_N 0.02173f
C1357 PULLUP_P_BLEED_4 PULLUP_P_BLEED_6 0.00326f
C1358 FS_P_GATE HS_P 1.05827f
C1359 HS_N_5 HS_N_10 0
C1360 HS_N_4 PULLUP_P_WELL 0.12026f
C1361 HS_P_2 HS_N_4 0.00376f
C1362 TERM_GATE_P HS_N_9 0.13605f
C1363 HS_N_3 DIV_N 0.03505f
C1364 FS_HIGH_P PULLUP_P 0.06616f
C1365 FS_LOW_P TERM_OR_P_B 1.1369f
C1366 HS_P HS_N_10 0.25322f
C1367 HS_N_6 TERM_N_R 0.1093f
C1368 FS_N_GATE HS_PBIAS 3.08633f
C1369 TERM_OR_N_S TERM_VCM 0
C1370 FS_N_BLEED_4 TERM_N_R 0.06105f
C1371 PULLUP_N_OUT PULLUP_P_OUT 0.17355f
C1372 HS_N_3 FS_LOW_N 0.08441f
C1373 PULLUP_P_CONTROL_S HS_N_10 0.04949f
C1374 PAD_P FS_N_OUT 0.17964f
C1375 HS_N_0 TERM_VCM 0.17286f
C1376 TERM_OR_P_S TERM_OR_P_B 1.83456f
C1377 DIV_ENABLE TERM_N_R 0.09755f
C1378 FS_LOW_P FS_N_OUT 0.5386f
C1379 HS_P_6 HS_P_12 0.07018f
C1380 VDD HS_P_0 3.95338f
C1381 PULLUP_N_OUT PULLUP_P_BLEED_2 0
C1382 PULLDOWN_P TERM_GATE_N_BLEED_2 0.07928f
C1383 FS_N_BLEED_5 PULLUP_N_GATE 0
C1384 HS_N_2 TERM_VCM 0.12019f
C1385 HS_N_6 PULLDOWN_P_R 0.02404f
C1386 HS_P_13 HS_P_6 0.15959f
C1387 TERM_ENABLE VCM_LOW_OK 0.27082f
C1388 FS_HIGH_P HS_N_12 0.02428f
C1389 TERM_ENABLE FS_P_WELL 2.50111f
C1390 DIV_LOW_P HS_N_12 0.00136f
C1391 PULLUP_P_BLEED_6 HS_N_9 0.00148f
C1392 HS_PBIAS HS_P_6 2.09103f
C1393 FS_HIGH_N PULLUP_N_WELL 0.30788f
C1394 TERM_GATE_N_BLEED_1 HS_N_8 0.0525f
C1395 HS_N_2 HS_P_1 0.09798f
C1396 PULLUP_P_BLEED_3 TERM_P_R 0.04766f
C1397 FS_P_CONTROL_S HS_N_0 0.03296f
C1398 RX_P DIV_P 1.39534f
C1399 HS_PBIAS PULLUP_P 0.35017f
C1400 HS_N_1 FS_HIGH_P 0.03577f
C1401 HS_N_1 DIV_LOW_P 0.00376f
C1402 HS_P_2 HS_P_6 0.06956f
C1403 PULLUP_P_WELL PULLUP_P 0.15487f
C1404 HS_N_5 TERM_P_R 0.05893f
C1405 PULLUP_P_BLEED_4 FS_N_OUT 0.06408f
C1406 TERM_GATE_P VCM_LOW_OK 0.20188f
C1407 FS_P_BLEED_1 HS_N_9 0.03472f
C1408 PULLUP_P_GATE FS_P_BLEED_2 0
C1409 HS_P_12 HS_N_12 0.08272f
C1410 FS_P_BLEED_4 HS_N_12 0.06178f
C1411 FS_P_CONTROL_S HS_N_2 0.03226f
C1412 FS_N_WELL FS_N_OUT 0.1934p
C1413 HS_N_8 HS_P_4 0.02404f
C1414 HS_P_13 HS_N_12 0.02465f
C1415 TERM_P_R HS_P 0.07234f
C1416 RX_P FS_P_OUT 0.01238f
C1417 HS_N_1 HS_P_12 0.06335f
C1418 HS_PBIAS HS_N_12 4.90809f
C1419 FS_LOW_P FS_N_CONTROL_S 0.04634f
C1420 PULLDOWN_P TERM_GATE_N 0.15548f
C1421 HS_N_1 FS_P_BLEED_4 0.06178f
C1422 PULLUP_P DIFF_ENABLE 0.20063f
C1423 HS_PBIAS PULLDOWN_N 0.03743f
C1424 PAD_P HS_N_13 0.08152f
C1425 PULLUP_P_WELL HS_N_12 0.12571f
C1426 TERM_OR_P_B HS_N_9 0.07254f
C1427 HS_P_10 TERM_OR_P_NS 0.04329f
C1428 HS_N_1 HS_P_13 0.12155f
C1429 FS_N_BLEED_2 PULLUP_N_WELL 0
C1430 HS_N_1 HS_PBIAS 2.51285f
C1431 PULLUP_P_BLEED_6 VCM_LOW_OK 0
C1432 VDD TERM_VCM 40.0278f
C1433 FS_LOW_P HS_N_13 0.08505f
C1434 TERM_ENABLE PULLUP_N_BLEED_3 0.01168f
C1435 DIV_LOW_N HS_N_0 0.06837f
C1436 HS_N_1 PULLUP_P_WELL 0.1499f
C1437 HS_N_3 PULLUP_P_GATE 0.08296f
C1438 TERM_ENABLE FS_N_BLEED_1 0.01168f
C1439 FS_LOW_P FS_N_BLEED_6 0.05624f
C1440 DIV_N TERM_VCM 0.67599f
C1441 PULLDOWN_P TERM_N_R 0.20782f
C1442 HS_N_3 TERM_GATE_N_BLEED_0 0.03489f
C1443 VDD HS_P_1 5.54122f
C1444 HS_N_1 HS_P_2 0.00649f
C1445 HS_P_3 TERM_ENABLE 0.0768f
C1446 FS_P_BLEED_1 VCM_LOW_OK 0.0381f
C1447 FS_P_BLEED_1 FS_P_WELL 0.02734f
C1448 HS_N_3 HS_N_4 0.12319p
C1449 FS_LOW_N TERM_VCM 0.11348f
C1450 PULLUP_P_BLEED_5 TERM_ENABLE 0
C1451 VDD FS_N_BLEED_0 0.04218f
C1452 DIFF_ENABLE PULLDOWN_N 0.37137f
C1453 FS_N_BLEED_5 PULLUP_N_WELL 0
C1454 DIV_LOW_N HS_N_2 0.06178f
C1455 PULLUP_P_BLEED_4 HS_N_13 0.0525f
C1456 TERM_VCM TERM_OR_N_B 0.10825f
C1457 HS_N_7 PULLDOWN_N_R 0.06832f
C1458 VDD FS_P_CONTROL_S 0.38621f
C1459 TERM_GATE_P_BLEED_0 HS_P_0 0.00591f
C1460 FS_N_CONTROL_S FS_N_WELL 0.9381f
C1461 HS_P_3 TERM_GATE_P 0.15659f
C1462 PULLDOWN_P PULLDOWN_P_R 2.2366f
C1463 PULLUP_N_BLEED_4 PULLDOWN_N_R 0
C1464 HS_N FS_P_BLEED_6 0.08043f
C1465 HS_P_9 HS_P_4 0.042f
C1466 TERM_VCM BYPASS_ENABLE 0.00889f
C1467 FS_P_BLEED_0 TERM_N_R 0.11444f
C1468 FS_HIGH_P PULLUP_P_BLEED_3 0.166f
C1469 HS_N TERM_OR_N_NS 0.04764f
C1470 FS_LOW_N FS_N_BLEED_0 0.00206f
C1471 VCM_LOW_OK TERM_OR_P_B 2.10826f
C1472 FS_N_WELL HS_N_13 0.00988f
C1473 FS_HIGH_P HS_N_5 0.02404f
C1474 HS_N PULLUP_N_GATE 0.16548f
C1475 HS_P_0 HS_N_4 0.03432f
C1476 PULLUP_P_BLEED_1 TERM_N_R 0.05729f
C1477 FS_N_OUT FS_P_WELL 0.93211f
C1478 PULLUP_P_BLEED_2 PULLUP_P_BLEED_0 0.10891f
C1479 FS_HIGH_P PULLUP_P_CONTROL_S 0.12623f
C1480 FS_N_OUT VCM_LOW_OK 0.1125f
C1481 FS_HIGH_P HS_P 0.02404f
C1482 TERM_ENABLE PULLUP_N_OUT 0.19202f
C1483 PULLUP_N_BLEED_0 PULLDOWN_N_R 0.07928f
C1484 FS_P_BLEED_2 HS_N_12 0
C1485 FS_P_BLEED_0 PULLDOWN_P_R 0.10124f
C1486 FS_P_BLEED_6 PULLUP_P_OUT 0.15208f
C1487 HS_N_3 HS_P_6 0.05828f
C1488 HS_N_5 HS_P_12 0.06578f
C1489 FS_N_OUT PAD_N 4.09186f
C1490 HS_N_6 FS_P_BLEED_5 0.06178f
C1491 HS_N_3 PULLUP_P 0.02404f
C1492 HS_N_5 FS_P_BLEED_4 0.06219f
C1493 HS_N_13 HS_N_9 0.08666f
C1494 RX_N RX_P 12.5825f
C1495 HS_N_7 HS_N_11 0.02985f
C1496 HS_N_1 FS_P_BLEED_2 0
C1497 PULLUP_P_BLEED_5 PULLUP_P_BLEED_6 3.1342f
C1498 TERM_GATE_P PULLUP_N_OUT 0.37427f
C1499 HS_P HS_P_12 3.63983f
C1500 HS_N PULLUP_N_BLEED_1 0.06387f
C1501 HS_N_5 HS_P_13 0.05493f
C1502 DIV_LOW_N VDD 0.25658f
C1503 PULLUP_P_BLEED_3 HS_PBIAS 0.04828f
C1504 FS_P_BLEED_4 HS_P 0.06337f
C1505 PAD_P HS_P_8 1.09993f
C1506 HS_N_5 HS_PBIAS 4.87448f
C1507 PULLUP_P_BLEED_3 PULLUP_P_WELL 0.00303f
C1508 HS_N_2 HS_P_10 0.03089f
C1509 PULLUP_N_BLEED_6 PULLUP_N_GATE 6.07282f
C1510 HS_P_13 HS_P 0.71007f
C1511 TERM_GATE_N_BLEED_1 HS_N_10 0.0527f
C1512 HS_N_5 PULLUP_P_WELL 0.11805f
C1513 DIV_LOW_N DIV_N 6.86692f
C1514 FS_LOW_P HS_P_8 0.04566f
C1515 HS_N DIV_P 0.08005f
C1516 HS_P_2 HS_N_5 0.03089f
C1517 VDD TERM_GATE_P_BLEED_2 0.084f
C1518 HS_PBIAS HS_P 0.16546p
C1519 HS_PBIAS PULLUP_P_CONTROL_S 0.07486f
C1520 DIV_LOW_N FS_LOW_N 0.06178f
C1521 HS_P_0 HS_P_6 0.04603f
C1522 PULLUP_P_GATE TERM_VCM 0.12603f
C1523 HS_N_3 HS_N_12 0.03984f
C1524 PULLUP_P_WELL HS_P 0.18882f
C1525 PULLUP_P_WELL PULLUP_P_CONTROL_S 0.02696f
C1526 HS_P_3 TERM_OR_P_B 0.10238f
C1527 TERM_GATE_N_BLEED_0 TERM_VCM 0.04263f
C1528 TERM_GATE_P_BLEED_0 HS_P_1 0.05525f
C1529 HS_N_4 TERM_VCM 0.12411f
C1530 HS_P_2 HS_P 7.07711f
C1531 HS_N_3 HS_N_1 0.03945f
C1532 PAD_P HS_P_5 1.15443f
C1533 DIV_LOW_N BYPASS_ENABLE 0.00106f
C1534 HS_PBIAS PULLUP_N_BLEED_2 0.01633f
C1535 HS_N FS_P_OUT 20.4712f
C1536 PULLUP_N_OUT PULLUP_P_BLEED_6 0.09268f
C1537 VCM_LOW_OK HS_N_13 0.05893f
C1538 HS_N_13 FS_P_WELL 1.99138f
C1539 FS_LOW_P HS_P_5 0.17341f
C1540 HS_N_4 HS_P_1 0.0586f
C1541 PULLUP_N_BLEED_6 PULLUP_N_BLEED_1 0.00257f
C1542 DIFF_ENABLE HS_P 0.27285f
C1543 VDD FS_HIGH_N 0.2016f
C1544 HS_N PULLUP_N_WELL 0.46804f
C1545 HS_N_13 PAD_N 1.56314f
C1546 HS_N_7 FS_P_BLEED_3 0.03794f
C1547 FS_N_GATE TERM_VCM 0.90423f
C1548 FS_P_BLEED_1 PULLUP_N_OUT 0.06151f
C1549 HS_P_0 HS_N_12 0.04378f
C1550 HS_N_11 PULLDOWN_N_R 0.06159f
C1551 a_41005_204385# a_41005_203545# 0
C1552 VDD HS_P_10 6.63169f
C1553 FS_P_OUT PULLUP_P_OUT 0.56159f
C1554 FS_P_CONTROL_S HS_N_4 0.03226f
C1555 HS_N_7 HS_N_8 0.11965p
C1556 FS_LOW_N FS_HIGH_N 0.08748f
C1557 DIV_ENABLE FS_N_BLEED_4 0.03564f
C1558 HS_N_1 HS_P_0 0.04113f
C1559 FS_N_GATE FS_N_BLEED_0 0.40602f
C1560 FS_N_BLEED_3 TERM_P_R 0.11141f
C1561 DIV_ENABLE HS_N_6 0.03089f
C1562 PULLUP_N_OUT TERM_OR_P_B 0.20772f
C1563 PULLUP_N TERM_N_R 0.12734f
C1564 FS_HIGH_N BYPASS_ENABLE 0
C1565 TERM_VCM HS_P_6 0.09615f
C1566 TERM_P_R HS_P_4 0.1254f
C1567 HS_P_8 HS_N_9 0.10431f
C1568 TERM_VCM PULLUP_P 0.21883f
C1569 ESD_RAIL a_44789_189064# 13.9519f
C1570 PULLUP_N_BLEED_6 PULLUP_N_WELL 0.00637f
C1571 VDD FS_N_BLEED_2 0.01834f
C1572 PULLUP_N_OUT FS_N_OUT 0.50078f
C1573 PAD_P HS_P_11 1.25724f
C1574 DIV_N RX_P 0.72665f
C1575 HS_P_6 HS_P_1 0.06271f
C1576 TERM_ENABLE PULLUP_P_BLEED_0 0.00606f
C1577 TERM_OR_P_NS PULLUP_P_OUT 0.1011f
C1578 HS_P_3 HS_N_13 0.02464f
C1579 FS_LOW_P HS_P_11 0.05239f
C1580 TERM_GATE_P_BLEED_0 TERM_GATE_P_BLEED_2 0.10759f
C1581 DIV_LOW_N HS_N_4 0.06178f
C1582 HS_N_3 PULLUP_P_BLEED_3 0.03489f
C1583 TERM_P_R PULLUP_N_CONTROL_S 0.0414f
C1584 FS_LOW_N FS_N_BLEED_2 0
C1585 VDD FS_N_BLEED_5 0.00257f
C1586 TERM_VCM HS_N_12 0.12019f
C1587 PULLUP_P_BLEED_5 HS_N_13 0.02404f
C1588 HS_P_5 HS_N_9 0.06578f
C1589 HS_N_3 HS_N_5 0.063f
C1590 RX_P BYPASS_ENABLE 4.95631f
C1591 TERM_ENABLE FS_P_BLEED_6 0.08457f
C1592 TERM_OR_N_NS TERM_ENABLE 0.06214f
C1593 HS_N_3 HS_P 0.21103f
C1594 HS_N_1 TERM_VCM 0.12324f
C1595 HS_N_8 PULLDOWN_N_R 0.02404f
C1596 HS_P_8 VCM_LOW_OK 0.03489f
C1597 HS_N_3 PULLUP_P_CONTROL_S 0.04808f
C1598 TERM_ENABLE PULLUP_N_GATE 0.24055f
C1599 FS_LOW_N FS_N_BLEED_5 0.084f
C1600 a_43813_189064# a_42245_162628# 0.00994f
C1601 HS_N TERM_OR_N_S 0.07589f
C1602 PULLUP_N_OUT FS_N_CONTROL_S 0.10706f
C1603 HS_P_8 PAD_N 0.85512f
C1604 HS_N HS_N_0 0.13467p
C1605 HS_N_1 HS_P_1 0.09066f
C1606 FS_HIGH_P TERM_GATE_N_BLEED_1 0.01347f
C1607 FS_P_CONTROL_S HS_N_12 0.03226f
C1608 PULLDOWN_P FS_N_BLEED_4 0.04811f
C1609 HS_P_0 HS_N_5 0.03733f
C1610 FS_HIGH_P FS_N_BLEED_3 0
C1611 PULLUP_N_OUT HS_N_13 0.05062f
C1612 HS_N_6 PULLDOWN_P 0.04428f
C1613 TERM_GATE_P_BLEED_0 HS_P_10 0.03777f
C1614 DIV_ENABLE PULLDOWN_P 0.04428f
C1615 HS_N_1 FS_P_CONTROL_S 0.0324f
C1616 HS_N HS_N_2 6.83901f
C1617 HS_N_11 FS_P_BLEED_3 0.029f
C1618 VCM_LOW_OK HS_P_5 0.03489f
C1619 HS_P_0 HS_P 17.7665f
C1620 DIV_LOW_N PULLUP_P 0.10124f
C1621 HS_N_0 PULLUP_P_OUT 0.03489f
C1622 HS_N_4 HS_P_10 0.07706f
C1623 FS_N_GATE FS_HIGH_N 8.87893f
C1624 HS_P_5 PAD_N 1.55482f
C1625 HS_N_8 HS_N_11 0.03489f
C1626 FS_P_BLEED_0 HS_N_6 0.06178f
C1627 HS_P_11 HS_N_9 0.03103f
C1628 TERM_OR_N_NS PULLUP_P_BLEED_6 0
C1629 ESD_RAIL a_41005_203545# 96.5489f
C1630 HS_P_4 HS_P_12 0
C1631 TERM_GATE_N_BLEED_1 HS_PBIAS 0.07928f
C1632 HS_N_7 FS_P_GATE 1.04462f
C1633 FS_N_BLEED_3 HS_PBIAS 0.08856f
C1634 FS_LOW_P TERM_GATE_N 0.04939f
C1635 HS_N_2 PULLUP_P_OUT 0.03489f
C1636 HS_P_9 PULLDOWN_N_R 4.1634f
C1637 HS_P_13 HS_P_4 0.14463f
C1638 DIV_LOW_N HS_N_12 0.06178f
C1639 HS_N_7 HS_N_10 0.03027f
C1640 HS_P_3 HS_P_8 0.03109f
C1641 TERM_GATE_P DIV_P 0.02274f
C1642 PAD_P TERM_N_R 0.19266f
C1643 HS_PBIAS HS_P_4 8.54683f
C1644 PULLUP_P_BLEED_3 TERM_VCM 0.03472f
C1645 TERM_ENABLE FS_P_OUT 0.53051f
C1646 DIV_LOW_N HS_N_1 0.06178f
C1647 PULLUP_N_BLEED_5 TERM_N_R 0.11444f
C1648 FS_HIGH_N PULLUP_P 0.04377f
C1649 HS_N_5 TERM_VCM 0.12535f
C1650 FS_LOW_P TERM_N_R 0.16749f
C1651 HS_P_2 HS_P_4 0.03986f
C1652 TERM_ENABLE PULLUP_N_WELL 0.52247f
C1653 TERM_GATE_N_BLEED_2 HS_N_9 0.04943f
C1654 VDD HS_N 2.60831f
C1655 TERM_OR_P_S TERM_N_R 0.0546f
C1656 TERM_GATE_P FS_P_OUT 0.22814f
C1657 HS_P_10 HS_P_6 0.07646f
C1658 FS_N_GATE FS_N_BLEED_2 0.19042f
C1659 HS_P_11 VCM_LOW_OK 0.06673f
C1660 TERM_VCM HS_P 0.21204f
C1661 PAD_P PULLDOWN_P_R 2.92129f
C1662 HS_N_5 HS_P_1 0.03097f
C1663 HS_P_3 HS_P_5 0.03192f
C1664 DIV_N HS_N 0.0509f
C1665 TERM_OR_N_NS FS_N_OUT 0.06103f
C1666 FS_LOW_P PULLDOWN_P_R 0.06539f
C1667 HS_P_11 PAD_N 1.42473f
C1668 HS_N_8 FS_P_BLEED_3 0.04176f
C1669 FS_P_BLEED_6 FS_N_OUT 0.04877f
C1670 HS_N FS_LOW_N 0.11362f
C1671 HS_P HS_P_1 4.17389f
C1672 TERM_ENABLE TERM_OR_P_NS 0.1642f
C1673 VDD PULLUP_P_OUT 3.24314f
C1674 FS_P_CONTROL_S HS_N_5 0.03226f
C1675 FS_N_BLEED_0 HS_P 0.09016f
C1676 FS_N_GATE FS_N_BLEED_5 0.25656f
C1677 PULLUP_N_OUT HS_P_8 0.0429f
C1678 FS_P_GATE PULLDOWN_N_R 1.47723f
C1679 HS_N_7 TERM_P_R 0.10033f
C1680 PULLUP_N_BLEED_4 TERM_P_R 0.04588f
C1681 FS_P_CONTROL_S HS_P 0.03246f
C1682 HS_N BYPASS_ENABLE 0.01049f
C1683 HS_P_10 HS_N_12 0.04371f
C1684 DIV_N PULLUP_P_OUT 0
C1685 FS_N_WELL TERM_N_R 1.45715f
C1686 PULLDOWN_N_R HS_N_10 0.02404f
C1687 FS_N_BLEED_2 PULLUP_P 0.10124f
C1688 TERM_GATE_N HS_N_9 0.05172f
C1689 PULLUP_P_BLEED_4 PULLDOWN_P_R 0.09196f
C1690 VDD PULLUP_N_BLEED_6 0.45117f
C1691 a_41005_206065# ESD_RAIL 0.57348f
C1692 VDD PULLUP_P_BLEED_2 0.57693f
C1693 HS_N_1 HS_P_10 0.0348f
C1694 TERM_OR_P_B DIV_P 0.0223f
C1695 FS_P_BLEED_1 FS_P_OUT 0
C1696 PULLUP_N_OUT HS_P_5 0.02859f
C1697 FS_LOW_N PULLUP_N_BLEED_6 0.06798f
C1698 TERM_N_R HS_N_9 0.0592f
C1699 a_53878_205785# a_53878_206345# 0.0346f
C1700 DIV_LOW_N HS_N_5 0.06178f
C1701 HS_P_3 HS_P_11 0.02877f
C1702 FS_N_OUT DIV_P 2.20134f
C1703 FS_P_GATE HS_N_11 1.0396f
C1704 HS_N_3 TERM_GATE_N_BLEED_1 0.0525f
C1705 FS_P_OUT TERM_OR_P_B 0.16122f
C1706 PULLUP_N_BLEED_6 BYPASS_ENABLE 0.00766f
C1707 FS_P_BLEED_6 HS_N_13 0.06178f
C1708 TERM_OR_N_NS HS_N_13 0.03425f
C1709 HS_N_11 HS_N_10 0.13802p
C1710 DIV_LOW_N HS_P 0.06178f
C1711 PULLDOWN_P_R HS_N_9 0.02404f
C1712 HS_N_8 HS_P_9 0.00649f
C1713 TERM_OR_N_S TERM_ENABLE 5.34793f
C1714 TERM_GATE_N VCM_LOW_OK 0.01725f
C1715 HS_N_0 TERM_ENABLE 0.10582f
C1716 FS_N_BLEED_6 PULLUP_N_GATE 0
C1717 FS_P_OUT FS_N_OUT 1.00178f
C1718 HS_N PULLUP_P_GATE 0.13616f
C1719 TERM_P_R PULLDOWN_N_R 0.14117f
C1720 HS_N TERM_GATE_N_BLEED_0 0.04828f
C1721 HS_N HS_N_4 1.43714f
C1722 FS_HIGH_P HS_N_7 0.02404f
C1723 TERM_GATE_P HS_N_0 0.11083f
C1724 a_41005_204385# ESD_RAIL 0.53823f
C1725 HS_N_2 TERM_ENABLE 0.04808f
C1726 VCM_LOW_OK TERM_N_R 0.18442f
C1727 TERM_N_R FS_P_WELL 1.63349f
C1728 TERM_GATE_P_BLEED_0 PULLUP_P_OUT 0.1011f
C1729 PAD_P HS_P_7 1.52213f
C1730 TERM_OR_P_NS TERM_OR_P_B 3.40561f
C1731 HS_P_11 PULLUP_N_OUT 0.08824f
C1732 TERM_N_R PAD_N 0.56726f
C1733 PULLUP_P_GATE PULLUP_P_OUT 19.8171f
C1734 a_53878_203545# a_53878_204105# 0.0346f
C1735 TERM_GATE_P HS_N_2 0.10747f
C1736 HS_P_0 HS_P_4 0.00219f
C1737 FS_LOW_P HS_P_7 0.04566f
C1738 HS_N FS_N_GATE 2.07022f
C1739 FS_HIGH_N HS_P 0.03743f
C1740 HS_N_5 HS_P_10 0.03089f
C1741 HS_N_7 HS_P_12 0.03489f
C1742 HS_N_7 FS_P_BLEED_4 0.06246f
C1743 PULLDOWN_P_R VCM_LOW_OK 0.06553f
C1744 PULLDOWN_P_R FS_P_WELL 3.25452f
C1745 HS_N_4 PULLUP_P_OUT 0.03489f
C1746 FS_P_GATE FS_P_BLEED_3 0.27756f
C1747 HS_N_11 TERM_P_R 0.05996f
C1748 HS_N_7 HS_P_13 0.02404f
C1749 HS_P_10 HS_P 2.44809f
C1750 PULLUP_P_GATE PULLUP_P_BLEED_2 0.1764f
C1751 PULLDOWN_P_R PAD_N 0.0844f
C1752 FS_P_BLEED_3 HS_N_10 0.02915f
C1753 FS_HIGH_P PULLUP_N_BLEED_0 0.01347f
C1754 HS_N_8 FS_P_GATE 1.04761f
C1755 HS_N_7 HS_PBIAS 9.64698f
C1756 TERM_GATE_N_BLEED_2 PULLUP_N_OUT 0.09196f
C1757 FS_P_OUT HS_N_13 0.52823f
C1758 HS_N_7 PULLUP_P_WELL 0.12519f
C1759 HS_N_8 HS_N_10 0.04444f
C1760 FS_P_BLEED_1 HS_N_0 0.03472f
C1761 HS_N HS_P_6 0.5265f
C1762 PULLDOWN_P PULLUP_N 5.21685f
C1763 VDD TERM_ENABLE 12.7928f
C1764 HS_N PULLUP_P 0.03743f
C1765 TERM_GATE_N_BLEED_1 TERM_VCM 0.00966f
C1766 HS_P_3 TERM_N_R 0.05037f
C1767 DIV_N TERM_ENABLE 0.00368f
C1768 FS_HIGH_P PULLDOWN_N_R 0.04377f
C1769 FS_N_BLEED_3 TERM_VCM 0.13759f
C1770 FS_N_BLEED_2 HS_P 0.08856f
C1771 FS_N_BLEED_6 PULLUP_N_WELL 0
C1772 FS_P_BLEED_1 HS_N_2 0.03472f
C1773 HS_N_0 TERM_OR_P_B 0.07497f
C1774 HS_PBIAS PULLUP_N_BLEED_0 0.07928f
C1775 VDD TERM_GATE_P 7.09843f
C1776 RX_N FS_N_OUT 0.01566f
C1777 TERM_ENABLE FS_LOW_N 0.36334f
C1778 TERM_VCM HS_P_4 0.12461f
C1779 PULLUP_P PULLUP_P_OUT 0.00257f
C1780 TERM_ENABLE TERM_OR_N_B 1.21894f
C1781 DIV_N TERM_GATE_P 0.00178f
C1782 HS_N HS_N_12 8.83112f
C1783 PULLDOWN_N_R HS_P_12 0.02404f
C1784 HS_P_7 HS_N_9 0.0401f
C1785 HS_N PULLDOWN_N 0.05791f
C1786 HS_N_0 FS_N_OUT 0.06167f
C1787 HS_P_3 PULLDOWN_P_R 0.07466f
C1788 FS_P_BLEED_4 PULLDOWN_N_R 0.05822f
C1789 FS_N_BLEED_3 FS_N_BLEED_0 0.10559f
C1790 PAD_P HS_N_6 2.14046f
C1791 HS_P_4 HS_P_1 0.03207f
C1792 HS_N_2 TERM_OR_P_B 0.07258f
C1793 TERM_GATE_N PULLUP_N_OUT 0.23412f
C1794 HS_N_1 HS_N 4.22798f
C1795 PULLDOWN_N_R HS_P_13 0.02404f
C1796 PULLUP_P PULLUP_P_BLEED_2 0.14463f
C1797 DIV_ENABLE PAD_P 0.14682f
C1798 PULLUP_N_BLEED_6 PULLUP_P 0.05764f
C1799 PULLUP_P_BLEED_5 PULLDOWN_P_R 0.09218f
C1800 FS_LOW_P FS_N_BLEED_4 0.23267f
C1801 FS_P_BLEED_5 HS_N_9 0.06178f
C1802 HS_N_8 TERM_P_R 0.05914f
C1803 HS_PBIAS PULLDOWN_N_R 0.82033f
C1804 FS_LOW_P HS_N_6 0.08542f
C1805 HS_N_12 PULLUP_P_OUT 0.03489f
C1806 TERM_VCM PULLUP_N_CONTROL_S 0.0423f
C1807 FS_HIGH_P HS_N_11 0.02435f
C1808 DIV_ENABLE FS_LOW_P 0.10858f
C1809 HS_N_11 DIV_LOW_P 0.00184f
C1810 PULLUP_P_WELL PULLDOWN_N_R 0.39593f
C1811 HS_P_2 PULLDOWN_N_R 0.07217f
C1812 PULLUP_N_OUT TERM_N_R 0.30705f
C1813 HS_N_1 PULLUP_P_OUT 0.03489f
C1814 VDD FS_P_BLEED_1 0.44675f
C1815 PULLUP_P_BLEED_4 HS_N_6 0.0525f
C1816 FS_LOW_N PULLUP_P_BLEED_6 0.02395f
C1817 PULLUP_N_BLEED_6 PULLDOWN_N 0
C1818 HS_N_11 HS_P_12 0.06914f
C1819 DIFF_ENABLE PULLDOWN_N_R 0.23599f
C1820 HS_N_11 FS_P_BLEED_4 0.06178f
C1821 HS_P_7 VCM_LOW_OK 0.03489f
C1822 DIV_N FS_P_BLEED_1 0.10151f
C1823 DIV_ENABLE PULLUP_P_BLEED_4 0
C1824 HS_N_11 HS_P_13 0.02487f
C1825 PULLUP_N_OUT PULLDOWN_P_R 0.10143f
C1826 HS_P_7 PAD_N 0.3613f
C1827 FS_N_WELL FS_N_BLEED_4 0.01068f
C1828 VDD TERM_OR_P_B 16.0128f
C1829 TERM_GATE_P_BLEED_0 TERM_ENABLE 0.09803f
C1830 HS_N_11 HS_PBIAS 2.65494f
C1831 TERM_OR_N_S HS_N_13 0.02464f
C1832 DIV_ENABLE FS_N_WELL 0.23482f
C1833 HS_N_3 HS_N_7 0.06865f
C1834 HS_N_11 PULLUP_P_WELL 0.13224f
C1835 PULLUP_P_GATE TERM_ENABLE 0.84363f
C1836 HS_N_0 HS_N_13 0.07993f
C1837 DIV_N TERM_OR_P_B 0.00135f
C1838 HS_P_9 TERM_P_R 0.11568f
C1839 TERM_GATE_N_BLEED_0 TERM_ENABLE 0.04931f
C1840 FS_P_BLEED_1 BYPASS_ENABLE 0.00766f
C1841 VDD FS_N_OUT 11.022f
C1842 FS_P_GATE HS_N_10 1.04113f
C1843 TERM_GATE_P_BLEED_0 TERM_GATE_P 4.84915f
C1844 HS_N_4 TERM_ENABLE 0.04808f
C1845 HS_N_2 HS_N_13 0.12568p
C1846 HS_N PULLUP_P_BLEED_3 0.04828f
C1847 HS_N_6 HS_N_9 0.04101f
C1848 FS_P_OUT HS_P_5 0.05462f
C1849 TERM_OR_P_NS HS_P_8 0.02846f
C1850 DIV_N FS_N_OUT 0.07775f
C1851 HS_N HS_N_5 4.65354f
C1852 DIV_ENABLE HS_N_9 0.03089f
C1853 FS_HIGH_P HS_N_8 0.03528f
C1854 TERM_GATE_P HS_N_4 0.11218f
C1855 FS_LOW_N FS_N_OUT 0.31306f
C1856 HS_P_0 HS_N_7 0
C1857 FS_N_GATE TERM_ENABLE 0.97699f
C1858 PULLUP_N_BLEED_5 PULLDOWN_P 0
C1859 HS_N PULLUP_P_CONTROL_S 0.11565f
C1860 FS_N_BLEED_3 FS_HIGH_N 0
C1861 HS_N HS_P 2.27647f
C1862 FS_P_BLEED_4 FS_P_BLEED_3 2.07149f
C1863 HS_P_3 HS_P_7 0.06116f
C1864 HS_N_8 HS_P_12 0.06335f
C1865 HS_N_5 PULLUP_P_OUT 0.03489f
C1866 HS_PBIAS FS_P_BLEED_3 0.07855f
C1867 PULLUP_P_GATE PULLUP_P_BLEED_6 1.78667f
C1868 HS_N_8 FS_P_BLEED_4 0.06266f
C1869 TERM_OR_P_NS HS_P_5 0.02846f
C1870 VDD FS_N_CONTROL_S 3.02358f
C1871 HS_N_8 HS_P_13 0.04828f
C1872 HS_N_3 PULLDOWN_N_R 0.02404f
C1873 PULLUP_P_WELL FS_P_BLEED_3 0
C1874 HS_P PULLUP_P_OUT 0.03526f
C1875 TERM_ENABLE HS_P_6 0.02404f
C1876 PULLUP_P_BLEED_3 PULLUP_P_BLEED_2 3.88784f
C1877 FS_P_GATE TERM_P_R 0.79885f
C1878 HS_P_10 HS_P_4 0
C1879 HS_N_8 HS_PBIAS 3.45151f
C1880 HS_N_6 FS_P_WELL 1.97843f
C1881 TERM_ENABLE PULLUP_P 0.04377f
C1882 FS_P_BLEED_1 PULLUP_P_GATE 0.00424f
C1883 HS_N_6 VCM_LOW_OK 0.05893f
C1884 HS_N_11 FS_P_BLEED_2 0
C1885 HS_N_8 PULLUP_P_WELL 0.13083f
C1886 VDD HS_N_13 7.11098f
C1887 DIV_ENABLE VCM_LOW_OK 0
C1888 TERM_P_R HS_N_10 0.06034f
C1889 HS_N_6 PAD_N 1.1595f
C1890 DIV_ENABLE FS_P_WELL 0.08405f
C1891 HS_P_2 HS_N_8 0.02404f
C1892 PULLDOWN_P FS_N_WELL 2.57755f
C1893 FS_P_BLEED_1 HS_N_4 0.03472f
C1894 TERM_GATE_P HS_P_6 0.15508f
C1895 PULLUP_N_BLEED_6 HS_P 0.04828f
C1896 VDD FS_N_BLEED_6 0.00257f
C1897 TERM_GATE_P_BLEED_0 TERM_OR_P_B 0.0048f
C1898 FS_N_BLEED_3 FS_N_BLEED_2 7.86857f
C1899 DIV_N HS_N_13 0.03462f
C1900 DIV_ENABLE PAD_N 0.03382f
C1901 HS_N_7 TERM_VCM 0.16639f
C1902 FS_LOW_N HS_N_13 0.08441f
C1903 PULLUP_N_BLEED_4 TERM_VCM 0.02041f
C1904 HS_P_0 PULLDOWN_N_R 0.03037f
C1905 PULLUP_N_OUT HS_P_7 0.02846f
C1906 TERM_ENABLE HS_N_12 0.08984f
C1907 PULLUP_N_BLEED_6 PULLUP_N_BLEED_2 0.00257f
C1908 HS_N_4 TERM_OR_P_B 0.07211f
C1909 PULLUP_N_OUT TERM_GATE_P_BLEED_1 0.05318f
C1910 HS_N_7 HS_P_1 0
C1911 FS_LOW_N FS_N_BLEED_6 0
C1912 PULLDOWN_P_R PULLUP_P_BLEED_0 0.01291f
C1913 HS_N_3 HS_N_11 0.03962f
C1914 FS_N_BLEED_3 FS_N_BLEED_5 0
C1915 FS_P_BLEED_6 TERM_N_R 0.05729f
C1916 TERM_OR_N_NS TERM_N_R 0.04867f
C1917 HS_N_1 TERM_ENABLE 0.04872f
C1918 PULLUP_N_OUT FS_P_BLEED_5 0.05922f
C1919 PULLUP_P_GATE FS_N_OUT 0.1125f
C1920 PULLUP_N_GATE TERM_N_R 0.17473f
C1921 TERM_GATE_P HS_N_12 0.10814f
C1922 HS_P_11 TERM_OR_P_NS 0.04285f
C1923 TERM_GATE_N_BLEED_0 FS_N_OUT 0.06167f
C1924 HS_P_9 HS_P_13 0.04877f
C1925 FS_P_CONTROL_S HS_N_7 0.03226f
C1926 PULLUP_P PULLUP_P_BLEED_6 0.14694f
C1927 HS_N_0 HS_P_5 0.03489f
C1928 HS_P_9 HS_PBIAS 3.39603f
C1929 HS_N_1 TERM_GATE_P 0.10974f
C1930 FS_N_BLEED_1 FS_N_BLEED_4 0.0078f
C1931 FS_P_BLEED_6 PULLDOWN_P_R 0.10124f
C1932 FS_P_BLEED_3 FS_P_BLEED_2 0.53961f
C1933 HS_P_3 HS_N_6 0.03089f
C1934 FS_N_GATE FS_N_OUT 0.14435p
C1935 FS_P_BLEED_0 HS_N_9 0.06178f
C1936 HS_P_2 HS_P_9 0.0419f
C1937 HS_P_0 HS_N_11 0.04389f
C1938 HS_N_2 HS_P_5 0.03489f
C1939 HS_N_6 PULLUP_P_BLEED_5 0.03334f
C1940 FS_HIGH_P FS_P_GATE 5.63212f
C1941 HS_P_6 TERM_OR_P_B 0.10133f
C1942 FS_HIGH_P HS_N_10 0.02442f
C1943 TERM_VCM PULLDOWN_N_R 0.28542f
C1944 DIV_LOW_P HS_N_10 0.00259f
C1945 PULLDOWN_P VCM_LOW_OK 0.04528f
C1946 FS_P_BLEED_1 HS_N_12 0.03472f
C1947 VDD HS_P_8 4.99906f
C1948 FS_P_GATE HS_P_12 0.00294f
C1949 DIV_LOW_N HS_N_7 0.06178f
C1950 HS_N_3 FS_P_BLEED_3 0.03144f
C1951 PULLDOWN_N_R HS_P_1 0.06544f
C1952 FS_P_GATE FS_P_BLEED_4 0.27551f
C1953 FS_N_OUT HS_P_6 0.06167f
C1954 PULLUP_P FS_N_OUT 0.52414f
C1955 PULLUP_P_GATE HS_N_13 0.08296f
C1956 FS_P_GATE HS_P_13 0.19446f
C1957 FS_N_BLEED_0 PULLDOWN_N_R 0.05188f
C1958 HS_N_1 FS_P_BLEED_1 0.03472f
C1959 HS_P_12 HS_N_10 0.07709f
C1960 TERM_GATE_N_BLEED_0 HS_N_13 0.03489f
C1961 PULLUP_N_BLEED_5 PULLUP_N 0.06639f
C1962 PULLUP_N_OUT FS_N_BLEED_4 0.05445f
C1963 HS_N_3 HS_N_8 0.03258f
C1964 HS_N_6 PULLUP_N_OUT 0.05599f
C1965 FS_P_BLEED_4 HS_N_10 0.06178f
C1966 FS_P_BLEED_0 FS_P_WELL 6.36796f
C1967 FS_P_OUT TERM_N_R 0.38548f
C1968 FS_P_GATE HS_PBIAS 1.80592f
C1969 HS_N_4 HS_N_13 0.14463f
C1970 FS_P_BLEED_0 VCM_LOW_OK 0.15599f
C1971 PULLUP_P_BLEED_3 TERM_ENABLE 0.05997f
C1972 TERM_OR_P_B HS_N_12 0.07307f
C1973 FS_N_GATE FS_N_CONTROL_S 0.98908f
C1974 HS_P_13 HS_N_10 0.0252f
C1975 DIV_ENABLE PULLUP_N_OUT 0.05062f
C1976 HS_N_5 TERM_ENABLE 0.08996f
C1977 FS_P_GATE PULLUP_P_WELL 0
C1978 PULLUP_N_WELL TERM_N_R 0.3392f
C1979 a_53878_204665# ESD_RAIL 0.53916f
C1980 VDD HS_P_5 4.75167f
C1981 HS_PBIAS HS_N_10 1.13923f
C1982 PULLUP_P_BLEED_1 VCM_LOW_OK 0.01462f
C1983 HS_N_1 TERM_OR_P_B 0.07438f
C1984 HS_N_11 TERM_VCM 0.12019f
C1985 PULLUP_P_WELL HS_N_10 0.14098f
C1986 FS_N_GATE HS_N_13 0.19342f
C1987 HS_N TERM_GATE_N_BLEED_1 0.10264f
C1988 HS_N_2 HS_P_11 0.03089f
C1989 TERM_ENABLE PULLUP_P_CONTROL_S 0
C1990 PULLDOWN_P_R FS_P_OUT 0.73833f
C1991 TERM_ENABLE HS_P 0.05441f
C1992 TERM_GATE_P HS_N_5 0.11502f
C1993 HS_N FS_N_BLEED_3 0.11535f
C1994 DIV_N HS_P_5 0.01203f
C1995 HS_P_0 HS_N_8 0.03523f
C1996 TERM_P_R DIV_LOW_P 0.00106f
C1997 PULLDOWN_P PULLUP_N_BLEED_3 0.00326f
C1998 FS_N_GATE FS_N_BLEED_6 2.79368f
C1999 HS_N_1 FS_N_OUT 0.06167f
C2000 PULLDOWN_P FS_N_BLEED_1 0.09712f
C2001 HS_N_0 TERM_GATE_N_BLEED_2 0.02492f
C2002 TERM_OR_P_NS TERM_N_R 0.1011f
C2003 HS_N HS_P_4 0.15877f
C2004 TERM_GATE_P HS_P 0.22621f
C2005 FS_N_CONTROL_S PULLUP_P 0.10706f
C2006 PULLUP_P_BLEED_5 PULLDOWN_P 0
C2007 HS_N_7 HS_P_10 0
C2008 TERM_P_R HS_P_12 0.11066f
C2009 HS_P_6 HS_N_13 0.05888f
C2010 a_41005_203825# a_41005_203545# 0.03725f
C2011 FS_P_CONTROL_S HS_N_11 0.03234f
C2012 DIV_LOW_N PULLDOWN_N_R 0.08856f
C2013 HS_N_2 TERM_GATE_N_BLEED_2 0.02404f
C2014 PULLUP_P HS_N_13 0.07466f
C2015 PULLUP_P_BLEED_3 PULLUP_P_BLEED_6 0
C2016 PULLDOWN_P_R TERM_OR_P_NS 0.05654f
C2017 HS_N_5 PULLUP_P_BLEED_6 0
C2018 TERM_P_R HS_P_13 0.08554f
C2019 HS_P_4 PULLUP_P_OUT 0.05519f
C2020 TERM_P_R HS_PBIAS 0.44602f
C2021 FS_HIGH_N PULLUP_N_BLEED_0 0.00933f
C2022 FS_P_BLEED_6 FS_P_BLEED_5 5.16949f
C2023 PULLUP_P_WELL TERM_P_R 0.29295f
C2024 VDD HS_P_11 5.06957f
C2025 TERM_GATE_P_BLEED_0 HS_P_8 0.0271f
C2026 PULLUP_P_BLEED_6 HS_P 0.00212f
C2027 FS_P_GATE FS_P_BLEED_2 0.11441f
C2028 FS_P_BLEED_1 HS_N_5 0.03472f
C2029 TERM_OR_N_S TERM_GATE_N 0.0189f
C2030 HS_P_2 TERM_P_R 0.08491f
C2031 HS_N_0 TERM_GATE_N 0.05542f
C2032 HS_N_12 HS_N_13 0.1359p
C2033 FS_P_BLEED_1 HS_P 0.03472f
C2034 PULLDOWN_P PULLUP_N_OUT 0.10073f
C2035 FS_P_BLEED_2 HS_N_10 0
C2036 HS_N_8 TERM_VCM 0.13427f
C2037 HS_N_1 HS_N_13 0.04843f
C2038 DIV_LOW_N HS_N_11 0.06178f
C2039 TERM_P_R DIFF_ENABLE 4.25629f
C2040 FS_HIGH_N PULLDOWN_N_R 0.03743f
C2041 HS_N_5 TERM_OR_P_B 0.07211f
C2042 HS_N_2 TERM_GATE_N 0.04808f
C2043 HS_N_8 HS_P_1 0.02866f
C2044 TERM_GATE_P_BLEED_0 HS_P_5 0.0244f
C2045 TERM_OR_N_S TERM_N_R 0.12114f
C2046 HS_N_0 TERM_N_R 0.13438f
C2047 PULLUP_P_BLEED_3 FS_N_OUT 0.06167f
C2048 HS_N_3 FS_P_GATE 1.03504f
C2049 HS_P TERM_OR_P_B 0.0917f
C2050 HS_P_10 PULLDOWN_N_R 0.07466f
C2051 FS_P_BLEED_0 PULLUP_N_OUT 0.11535f
C2052 FS_P_CONTROL_S HS_N_8 0.03238f
C2053 HS_N_4 HS_P_5 0.03511f
C2054 HS_N_2 TERM_N_R 0.0594f
C2055 HS_N_3 HS_N_10 0.03951f
C2056 FS_N_OUT HS_P 0.77167f
C2057 PULLUP_N_OUT PULLUP_P_BLEED_1 0
C2058 HS_N_0 PULLDOWN_P_R 0.02508f
C2059 PULLUP_P_CONTROL_S FS_N_OUT 0.05082f
C2060 HS_P_8 HS_P_6 0.00206f
C2061 FS_LOW_P TERM_OR_P_S 0.36544f
C2062 HS_N_6 FS_P_BLEED_6 0.06178f
C2063 HS_N_6 TERM_OR_N_NS 0.03425f
C2064 FS_N_BLEED_4 PULLUP_N_GATE 0.00498f
C2065 FS_N_BLEED_2 PULLDOWN_N_R 0.08856f
C2066 TERM_VCM HS_P_9 0.1405f
C2067 FS_HIGH_P HS_PBIAS 0.07608f
C2068 HS_PBIAS DIV_LOW_P 0
C2069 HS_N_2 PULLDOWN_P_R 0.02404f
C2070 FS_HIGH_P PULLUP_P_WELL 0.27585f
C2071 VDD TERM_GATE_N 3.74877f
C2072 DIV_ENABLE PULLUP_N_GATE 0
C2073 a_41005_205505# a_41005_204945# 0.0346f
C2074 HS_P_0 HS_N_10 0.06989f
C2075 HS_P_10 HS_N_11 0.1403f
C2076 HS_P_13 HS_P_12 47.0352f
C2077 FS_LOW_P PULLUP_P_BLEED_4 0.0781f
C2078 HS_P_9 HS_P_1 0.03494f
C2079 TERM_GATE_P_BLEED_0 HS_P_11 0.03689f
C2080 DIV_N TERM_GATE_N 0.02552f
C2081 HS_PBIAS HS_P_12 4.10448f
C2082 DIV_LOW_N HS_N_8 0.06178f
C2083 PULLUP_P_BLEED_3 HS_N_13 0.03489f
C2084 HS_P_7 TERM_OR_P_NS 0.02846f
C2085 HS_P_5 HS_P_6 32.3343f
C2086 PULLUP_N_BLEED_3 PULLUP_N 0.121f
C2087 FS_P_BLEED_4 HS_PBIAS 0.09926f
C2088 FS_LOW_P FS_N_WELL 1.46084f
C2089 FS_LOW_N TERM_GATE_N 0.09048f
C2090 HS_P_2 HS_P_12 0.00206f
C2091 HS_N_3 TERM_P_R 0.05893f
C2092 HS_N_5 HS_N_13 0.10387f
C2093 PULLUP_P_WELL FS_P_BLEED_4 0
C2094 HS_PBIAS HS_P_13 2.35188f
C2095 VDD TERM_N_R 6.88046f
C2096 FS_N_CONTROL_S HS_P 0.09439f
C2097 FS_HIGH_P DIFF_ENABLE 0.2074f
C2098 TERM_GATE_N TERM_OR_N_B 1.45686f
C2099 HS_N_4 HS_P_11 0.06606f
C2100 TERM_GATE_N_BLEED_1 TERM_ENABLE 0.07928f
C2101 HS_P_2 HS_P_13 36.317f
C2102 a_41005_203825# a_41005_204385# 0.0346f
C2103 HS_P HS_N_13 0.10519f
C2104 DIV_N TERM_N_R 0.14748f
C2105 FS_N_BLEED_3 TERM_ENABLE 0.11535f
C2106 PULLUP_P_WELL HS_PBIAS 0.52241f
C2107 PULLUP_P_CONTROL_S HS_N_13 0.04867f
C2108 PAD_P HS_N_9 1.20851f
C2109 HS_P_2 HS_PBIAS 3.95109f
C2110 FS_LOW_N TERM_N_R 0.11177f
C2111 a_41684_232275# a_41684_220611# 1.22075p
C2112 HS_N HS_N_7 0.69419f
C2113 VDD PULLDOWN_P_R 1.92312f
C2114 FS_N_BLEED_6 HS_P 0.11073f
C2115 HS_P_5 HS_N_12 0.03489f
C2116 FS_LOW_P HS_N_9 0.08576f
C2117 TERM_ENABLE HS_P_4 0.07923f
C2118 FS_P_GATE TERM_VCM 0.64724f
C2119 TERM_OR_N_B TERM_N_R 5.91987f
C2120 DIV_ENABLE DIV_P 4.76769f
C2121 HS_P_0 TERM_P_R 0.07626f
C2122 TERM_VCM HS_N_10 0.12019f
C2123 TERM_GATE_N_BLEED_0 TERM_GATE_N_BLEED_2 0.00153f
C2124 HS_PBIAS DIFF_ENABLE 0.27859f
C2125 HS_N_1 HS_P_5 0.03489f
C2126 HS_N_6 FS_P_OUT 0.43331f
C2127 HS_N_4 TERM_GATE_N_BLEED_2 0.02921f
C2128 TERM_GATE_P HS_P_4 0.15627f
C2129 FS_HIGH_P FS_P_BLEED_2 0.03577f
C2130 FS_LOW_N PULLDOWN_P_R 0.00169f
C2131 PULLUP_N_WELL FS_N_BLEED_4 0.01353f
C2132 DIV_ENABLE FS_P_OUT 0.0629f
C2133 PULLUP_N_OUT PULLUP_N 0.03945f
C2134 TERM_OR_N_NS PULLDOWN_P 0.04764f
C2135 a_41005_205505# m2_42279_196800# 0
C2136 HS_N_8 HS_P_10 0.0286f
C2137 HS_N_7 PULLUP_P_OUT 0.03489f
C2138 TERM_ENABLE PULLUP_N_CONTROL_S 0.07644f
C2139 PULLUP_P_BLEED_4 HS_N_9 0.0525f
C2140 HS_P_11 HS_P_6 0.06713f
C2141 PULLDOWN_P PULLUP_N_GATE 0.18497f
C2142 HS_N PULLUP_N_BLEED_0 0.12943f
C2143 DIV_ENABLE PULLUP_N_WELL 0.06147f
C2144 FS_P_CONTROL_S FS_P_GATE 1.45056f
C2145 PAD_P VCM_LOW_OK 0.00567f
C2146 a_41005_204945# m2_42279_196800# 0
C2147 FS_N_WELL HS_N_9 0.00889f
C2148 PULLUP_P_BLEED_1 PULLUP_P_BLEED_0 0.83843f
C2149 FS_P_BLEED_4 FS_P_BLEED_2 0.12224f
C2150 PAD_P PAD_N 55.5639f
C2151 FS_P_CONTROL_S HS_N_10 0.03236f
C2152 PULLUP_N_BLEED_4 PULLUP_N_BLEED_6 0.00855f
C2153 FS_LOW_P VCM_LOW_OK 0.29172f
C2154 HS_N_0 FS_P_BLEED_5 0.06178f
C2155 FS_LOW_P FS_P_WELL 1.90293f
C2156 HS_N_6 TERM_OR_P_NS 0.00351f
C2157 HS_N_3 FS_HIGH_P 0.02404f
C2158 TERM_OR_P_S VCM_LOW_OK 1.87902f
C2159 TERM_GATE_N_BLEED_0 TERM_GATE_N 4.39906f
C2160 PULLDOWN_P PULLUP_N_BLEED_1 0.06517f
C2161 HS_N_4 TERM_GATE_N 0.04808f
C2162 HS_P_11 HS_N_12 0.11035f
C2163 PULLUP_P_WELL FS_P_BLEED_2 0
C2164 HS_N_2 FS_P_BLEED_5 0.06178f
C2165 TERM_GATE_P_BLEED_0 TERM_N_R 0.14463f
C2166 HS_N PULLDOWN_N_R 0.12564f
C2167 TERM_VCM TERM_P_R 0.19926p
C2168 TERM_GATE_N_BLEED_2 PULLUP_P 0.09196f
C2169 HS_N_1 HS_P_11 0.02846f
C2170 HS_N_3 HS_P_12 0.03489f
C2171 PULLUP_P_BLEED_4 VCM_LOW_OK 0
C2172 PULLUP_P_GATE TERM_N_R 0.16992f
C2173 HS_P_8 HS_P 3.0077f
C2174 PULLUP_N_BLEED_6 PULLUP_N_BLEED_0 0.00257f
C2175 HS_N_3 FS_P_BLEED_4 0.06178f
C2176 HS_P_10 HS_P_9 0.00887f
C2177 TERM_GATE_N_BLEED_0 TERM_N_R 0.17977f
C2178 TERM_P_R HS_P_1 0.10249f
C2179 HS_N_3 HS_P_13 0.02404f
C2180 HS_N_4 TERM_N_R 0.05893f
C2181 TERM_GATE_P_BLEED_0 PULLDOWN_P_R 0.12409f
C2182 TERM_GATE_N_BLEED_1 FS_N_OUT 0.06408f
C2183 PULLDOWN_N_R PULLUP_P_OUT 0.10342f
C2184 DIV_LOW_N HS_N_10 0.06178f
C2185 HS_P_4 TERM_OR_P_B 0.10189f
C2186 HS_N_3 HS_PBIAS 1.07017f
C2187 PULLUP_P_GATE PULLDOWN_P_R 0.39874f
C2188 HS_N_3 PULLUP_P_WELL 0.11601f
C2189 HS_N_5 HS_P_5 0.10295f
C2190 TERM_GATE_N_BLEED_2 HS_N_12 0.02427f
C2191 FS_N_GATE TERM_N_R 0.76877f
C2192 PAD_P HS_P_3 1.68578f
C2193 PULLUP_N_BLEED_5 PULLUP_N_BLEED_3 0.10602f
C2194 VDD HS_P_7 4.96081f
C2195 DIV_ENABLE RX_N 0.7437f
C2196 HS_P_0 HS_P_12 0.08899f
C2197 HS_N_4 PULLDOWN_P_R 0.02404f
C2198 PULLUP_N_BLEED_6 PULLDOWN_N_R 0.04864f
C2199 HS_P_5 HS_P 5.05127f
C2200 FS_LOW_P FS_N_BLEED_1 0.23767f
C2201 a_41005_203825# ESD_RAIL 0.53823f
C2202 HS_N HS_N_11 5.51295f
C2203 FS_LOW_P HS_P_3 0.04607f
C2204 HS_N_1 TERM_GATE_N_BLEED_2 0.02451f
C2205 PULLDOWN_P PULLUP_N_WELL 0.47103f
C2206 TERM_GATE_N PULLUP_P 0.21883f
C2207 VDD TERM_GATE_P_BLEED_1 0.07121f
C2208 TERM_OR_N_S HS_N_6 0.02755f
C2209 HS_N_6 HS_N_0 0.04157f
C2210 HS_P_0 HS_P_13 0.01899f
C2211 a_53878_205225# a_53878_205785# 0.0346f
C2212 FS_P_WELL HS_N_9 2.02035f
C2213 VCM_LOW_OK HS_N_9 0.05893f
C2214 HS_P_0 HS_PBIAS 0.94883f
C2215 DIV_ENABLE HS_N_0 2.34864f
C2216 PAD_N HS_N_9 1.0992f
C2217 HS_N_11 PULLUP_P_OUT 0.03489f
C2218 HS_N_2 HS_N_6 0
C2219 HS_P_2 HS_P_0 0.00431f
C2220 PULLUP_P TERM_N_R 0.34532f
C2221 TERM_GATE_N HS_N_12 0.04844f
C2222 FS_HIGH_P TERM_VCM 0.13992f
C2223 TERM_VCM DIV_LOW_P 0.00257f
C2224 PULLUP_P_BLEED_4 PULLUP_P_BLEED_5 4.64605f
C2225 DIV_ENABLE HS_N_2 0.03089f
C2226 DIV_LOW_N TERM_P_R 0.0414f
C2227 TERM_GATE_N_BLEED_1 HS_N_13 0.0525f
C2228 HS_P_10 HS_N_10 0.09288f
C2229 FS_N_BLEED_1 FS_N_WELL 0.5326f
C2230 PAD_P PULLUP_N_OUT 0.11127f
C2231 HS_N_1 TERM_GATE_N 0.05139f
C2232 PULLDOWN_P_R HS_P_6 0.02404f
C2233 HS_N_5 HS_P_11 0.03089f
C2234 FS_LOW_P PULLUP_N_OUT 0.07132f
C2235 HS_N_7 TERM_ENABLE 0.10575f
C2236 TERM_P_R TERM_GATE_P_BLEED_2 0.06551f
C2237 PULLDOWN_P_R PULLUP_P 0.09196f
C2238 HS_N FS_P_BLEED_3 0.0463f
C2239 VCM_LOW_OK FS_P_WELL 1.23126f
C2240 TERM_VCM HS_P_12 0.107f
C2241 TERM_N_R HS_N_12 0.0597f
C2242 FS_HIGH_P FS_N_BLEED_0 0.00106f
C2243 PULLDOWN_N TERM_N_R 0.05478f
C2244 HS_P_11 HS_P 5.65023f
C2245 PULLUP_N_GATE PULLUP_N 1.36429f
C2246 PULLUP_N_BLEED_4 TERM_ENABLE 0.08954f
C2247 FS_HIGH_P FS_P_CONTROL_S 0.51548f
C2248 TERM_VCM HS_P_13 0.09664f
C2249 TERM_GATE_P HS_N_7 0.12198f
C2250 HS_N HS_N_8 2.66346f
C2251 HS_N_1 TERM_N_R 0.06392f
C2252 HS_P_12 HS_P_1 0.05935f
C2253 HS_P_3 HS_N_9 0.03089f
C2254 TERM_VCM HS_PBIAS 0.70648f
C2255 PULLUP_P_BLEED_4 PULLUP_N_OUT 0.09196f
C2256 PULLUP_P_BLEED_5 HS_N_9 0.04943f
C2257 PULLUP_P_WELL TERM_VCM 0.28547f
C2258 PULLDOWN_P_R HS_N_12 0.02424f
C2259 VDD FS_N_BLEED_4 0.45117f
C2260 VDD HS_N_6 6.90044f
C2261 HS_N_5 TERM_GATE_N_BLEED_2 0.03089f
C2262 FS_P_BLEED_3 PULLUP_P_OUT 0.00257f
C2263 FS_HIGH_N TERM_P_R 0.05398f
C2264 HS_P_13 HS_P_1 0.11352f
C2265 HS_P_2 TERM_VCM 0.09615f
C2266 HS_PBIAS HS_P_1 2.59892f
C2267 TERM_GATE_P_BLEED_0 HS_P_7 0.02404f
C2268 DIV_ENABLE VDD 0.3424f
C2269 a_42245_162628# a_44789_189064# 10.1844f
C2270 PULLUP_N_OUT FS_N_WELL 2.10234f
C2271 TERM_OR_N_S PULLDOWN_P 0.10193f
C2272 HS_N_1 PULLDOWN_P_R 0.02445f
C2273 DIV_N HS_N_6 0.03462f
C2274 PULLUP_N PULLUP_N_BLEED_1 0.31155f
C2275 TERM_GATE_N_BLEED_2 HS_P 0.10446f
C2276 HS_P_10 TERM_P_R 0.14229f
C2277 HS_N_0 PULLDOWN_P 0.04428f
C2278 TERM_GATE_P_BLEED_0 TERM_GATE_P_BLEED_1 2.63577f
C2279 FS_N_BLEED_0 HS_PBIAS 0.10276f
C2280 HS_N_8 PULLUP_P_OUT 0.0351f
C2281 HS_N_6 FS_LOW_N 0.08478f
C2282 HS_P_2 HS_P_1 0.0568f
C2283 FS_LOW_N FS_N_BLEED_4 0.07141f
C2284 FS_P_CONTROL_S HS_PBIAS 0.04861f
C2285 HS_N_7 PULLUP_P_BLEED_6 0
C2286 DIV_ENABLE DIV_N 33.0875f
C2287 TERM_VCM DIFF_ENABLE 0.14773f
C2288 PULLUP_P_GATE FS_P_BLEED_5 0.01836f
C2289 DIV_ENABLE FS_LOW_N 0.0351f
C2290 DIV_LOW_N FS_HIGH_P 0.16534f
C2291 FS_N_BLEED_4 BYPASS_ENABLE 0.00766f
C2292 TERM_ENABLE PULLDOWN_N_R 0.07871f
C2293 HS_N_4 FS_P_BLEED_5 0.06178f
C2294 FS_P_BLEED_1 HS_N_7 0.03472f
C2295 HS_P_3 VCM_LOW_OK 0.09096f
C2296 PULLUP_N_OUT HS_N_9 0.01492f
C2297 FS_P_BLEED_0 HS_N_0 0.06178f
C2298 PULLUP_P_BLEED_5 VCM_LOW_OK 0
C2299 HS_N HS_P_9 0.12189f
C2300 FS_N_BLEED_2 TERM_P_R 0.04588f
C2301 DIV_ENABLE BYPASS_ENABLE 75.0001f
C2302 HS_P_3 PAD_N 0.257f
C2303 HS_N_5 TERM_GATE_N 0.04924f
C2304 TERM_GATE_P PULLDOWN_N_R 0.26213f
C2305 PULLUP_N_WELL PULLUP_N 0.61243f
C2306 TERM_GATE_N HS_P 0.05324f
C2307 HS_N_7 TERM_OR_P_B 0.07211f
C2308 FS_P_BLEED_0 HS_N_2 0.06178f
C2309 PULLUP_P_BLEED_3 TERM_N_R 0.06105f
C2310 HS_P_8 HS_P_4 0.0312f
C2311 DIV_LOW_N HS_PBIAS 0.09646f
C2312 HS_N_5 TERM_N_R 0.05893f
C2313 HS_P_9 PULLUP_P_OUT 0.06897f
C2314 HS_P_7 HS_P_6 31.6746f
C2315 FS_HIGH_P FS_HIGH_N 29.9593f
C2316 TERM_ENABLE HS_N_11 0.04853f
C2317 TERM_N_R HS_P 0.08926f
C2318 PULLUP_N_OUT FS_P_WELL 2.65652f
C2319 PULLUP_N_OUT VCM_LOW_OK 0.20396f
C2320 VDD PULLDOWN_P 1.69457f
C2321 PULLUP_P_BLEED_3 PULLDOWN_P_R 0.05462f
C2322 TERM_GATE_P_BLEED_0 HS_N_6 0
C2323 PULLUP_P_BLEED_6 PULLDOWN_N_R 0.05779f
C2324 HS_N_5 PULLDOWN_P_R 0.02404f
C2325 PULLUP_N_OUT PAD_N 1.29311f
C2326 TERM_GATE_P HS_N_11 0.10852f
C2327 a_42245_162628# a_41005_203545# 0.0135f
C2328 DIV_N PULLDOWN_P 0.0465f
C2329 HS_P_5 HS_P_4 32.9896f
C2330 HS_N_6 PULLUP_P_GATE 0.08451f
C2331 HS_N_3 TERM_VCM 0.12325f
C2332 HS_N FS_P_GATE 2.29474f
C2333 PULLDOWN_P_R PULLUP_P_CONTROL_S 0.08753f
C2334 TERM_GATE_N_BLEED_0 HS_N_6 0.03489f
C2335 PULLDOWN_P_R HS_P 0.03048f
C2336 FS_P_BLEED_1 PULLDOWN_N_R 0.05445f
C2337 DIV_ENABLE PULLUP_P_GATE 0
C2338 FS_LOW_P TERM_OR_N_NS 0.08185f
C2339 PULLDOWN_P FS_LOW_N 0.32332f
C2340 HS_N_6 HS_N_4 0.05831f
C2341 HS_N HS_N_10 3.58671f
C2342 DIV_ENABLE TERM_GATE_N_BLEED_0 0.01375f
C2343 FS_P_BLEED_0 VDD 0.66399f
C2344 HS_P_10 HS_P_12 0.07589f
C2345 FS_HIGH_N HS_PBIAS 0.03743f
C2346 PULLDOWN_P TERM_OR_N_B 0.04844f
C2347 FS_LOW_P PULLUP_N_GATE 0.10761f
C2348 PULLUP_N_BLEED_5 PULLUP_N_GATE 0.24191f
C2349 FS_P_BLEED_5 HS_N_12 0.06178f
C2350 DIV_ENABLE HS_N_4 0.03089f
C2351 HS_P_10 HS_P_13 0.09466f
C2352 FS_HIGH_P FS_N_BLEED_2 0
C2353 FS_N_GATE FS_N_BLEED_4 0.27893f
C2354 VDD PULLUP_P_BLEED_1 0.07323f
C2355 PULLDOWN_N_R TERM_OR_P_B 0.16954f
C2356 FS_P_GATE PULLUP_P_OUT 1.53435f
C2357 HS_P_10 HS_PBIAS 8.55407f
C2358 HS_N_1 FS_P_BLEED_5 0.06178f
C2359 HS_P_0 TERM_VCM 0.19537f
C2360 PULLUP_P_BLEED_4 TERM_OR_N_NS 0
C2361 HS_N_3 FS_P_CONTROL_S 0.03226f
C2362 DIV_ENABLE FS_N_GATE 0.00424f
C2363 HS_N_7 HS_N_13 0.09546f
C2364 PULLUP_P_OUT HS_N_10 0.03489f
C2365 HS_P_2 HS_P_10 0
C2366 FS_N_OUT PULLDOWN_N_R 0.56245f
C2367 PULLUP_N_OUT FS_N_BLEED_1 0.05216f
C2368 FS_HIGH_P FS_N_BLEED_5 0.01355f
C2369 FS_HIGH_N DIFF_ENABLE 0.2667f
C2370 HS_P_3 PULLUP_N_OUT 0.08633f
C2371 FS_P_BLEED_1 HS_N_11 0.03472f
C2372 HS_P_0 HS_P_1 36.4065f
C2373 PAD_P DIV_P 2.52939f
C2374 HS_N_8 TERM_ENABLE 0.04808f
C2375 HS_N_6 HS_P_6 0.06938f
C2376 HS_P_11 HS_P_4 0
C2377 PULLUP_P_BLEED_5 PULLUP_N_OUT 0.09196f
C2378 FS_N_BLEED_2 HS_PBIAS 0.08856f
C2379 HS_N_6 PULLUP_P 0.07466f
C2380 PULLUP_P FS_N_BLEED_4 0.05445f
C2381 FS_LOW_P DIV_P 2.36145f
C2382 HS_N TERM_P_R 0.11349f
C2383 TERM_GATE_P HS_N_8 0.12805f
C2384 HS_N_11 TERM_OR_P_B 0.07338f
C2385 DIV_ENABLE PULLUP_P 0.05123f
C2386 TERM_GATE_N_BLEED_1 TERM_GATE_N_BLEED_2 5.57305f
C2387 PAD_P FS_P_OUT 5.92309f
C2388 TERM_OR_N_NS HS_N_9 0.03425f
C2389 FS_P_BLEED_6 HS_N_9 0.06178f
C2390 DIV_LOW_N HS_N_3 0.06178f
C2391 PULLUP_P_GATE PULLDOWN_P 0.02056f
C2392 FS_LOW_P FS_P_OUT 0.53029f
C2393 HS_N_6 HS_N_12 0
C2394 FS_N_CONTROL_S PULLDOWN_N_R 0.09439f
C2395 TERM_P_R PULLUP_P_OUT 0.25969f
C2396 TERM_GATE_N_BLEED_0 PULLDOWN_P 0.04828f
C2397 HS_N_4 PULLDOWN_P 0.05303f
C2398 FS_LOW_P PULLUP_N_WELL 0.28858f
C2399 DIV_ENABLE HS_N_12 0.03143f
C2400 HS_N_8 PULLUP_P_BLEED_6 0.00108f
C2401 PULLDOWN_N_R HS_N_13 0.06832f
C2402 TERM_VCM HS_P_1 0.15005f
C2403 TERM_ENABLE HS_P_9 0.07435f
C2404 HS_P_7 HS_P 0.53303f
C2405 PULLUP_N_BLEED_6 TERM_P_R 0.04797f
C2406 DIV_ENABLE HS_N_1 0.03212f
C2407 HS_N_5 FS_P_BLEED_5 0.06178f
C2408 FS_N_GATE PULLDOWN_P 1.2359f
C2409 TERM_P_R PULLUP_P_BLEED_2 0.11063f
C2410 FS_P_BLEED_1 HS_N_8 0.03472f
C2411 FS_P_BLEED_0 HS_N_4 0.06178f
C2412 TERM_GATE_N_BLEED_1 TERM_GATE_N 0.42775f
C2413 FS_LOW_P TERM_OR_P_NS 0.39723f
C2414 FS_P_BLEED_6 VCM_LOW_OK 0.01451f
C2415 TERM_OR_N_NS VCM_LOW_OK 7.89319f
C2416 VDD PULLUP_N 0.00338f
C2417 FS_P_BLEED_5 HS_P 0.06178f
C2418 TERM_GATE_P HS_P_9 0.22051f
C2419 TERM_OR_P_S TERM_OR_P_NS 0.00736f
C2420 PULLUP_P_GATE PULLUP_P_BLEED_1 0.19163f
C2421 HS_N_8 TERM_OR_P_B 0.07245f
C2422 HS_N FS_HIGH_P 0.02498f
C2423 HS_N DIV_LOW_P 0.06611f
C2424 FS_N_OUT FS_P_BLEED_3 0.08101f
C2425 TERM_GATE_N_BLEED_1 TERM_N_R 0.07874f
C2426 HS_N_11 HS_N_13 0.09269f
C2427 PULLDOWN_P PULLUP_P 0.05412f
C2428 FS_N_BLEED_3 TERM_N_R 0.11444f
C2429 FS_P_OUT HS_N_9 0.43377f
C2430 HS_N_8 FS_N_OUT 0.06167f
C2431 PAD_P RX_N 0.37917f
C2432 HS_N_7 HS_P_5 0.03489f
C2433 TERM_N_R HS_P_4 0.05722f
C2434 FS_P_GATE TERM_ENABLE 1.00704f
C2435 HS_N HS_P_12 0.5567f
C2436 HS_N FS_P_BLEED_4 0.08043f
C2437 HS_P_0 HS_P_10 2.2381f
C2438 FS_HIGH_P PULLUP_P_OUT 0.10214f
C2439 DIV_LOW_N TERM_VCM 0.19527f
C2440 TERM_ENABLE HS_N_10 0.04862f
C2441 PULLDOWN_P HS_N_12 0.04428f
C2442 HS_N_6 PULLUP_P_BLEED_3 0.03489f
C2443 PAD_P HS_N_0 0.14558f
C2444 HS_N HS_P_13 0.35374f
C2445 VCM_LOW_OK DIV_P 0.00892f
C2446 HS_N HS_PBIAS 0.39831f
C2447 PULLDOWN_P PULLDOWN_N 2.04789f
C2448 HS_N_5 HS_N_6 0.12181p
C2449 PULLDOWN_P_R HS_P_4 0.07466f
C2450 FS_HIGH_P PULLUP_N_BLEED_6 0.08992f
C2451 FS_LOW_P HS_N_0 0.08516f
C2452 DIV_P PAD_N 0.47479f
C2453 HS_N PULLUP_P_WELL 0.29467f
C2454 DIV_ENABLE PULLUP_P_BLEED_3 0.01375f
C2455 TERM_VCM TERM_GATE_P_BLEED_2 0.02194f
C2456 PULLUP_N_BLEED_3 PULLUP_N_GATE 0.13233f
C2457 PULLUP_P PULLUP_P_BLEED_1 0.23767f
C2458 TERM_GATE_P HS_N_10 0.10903f
C2459 PULLUP_N_CONTROL_S TERM_N_R 0.05859f
C2460 TERM_OR_P_NS HS_N_9 0.01002f
C2461 DIV_ENABLE HS_N_5 0.03089f
C2462 FS_P_BLEED_4 PULLUP_P_OUT 0.00257f
C2463 HS_N_6 HS_P 1.04391f
C2464 RX_P HS_P_0 0
C2465 HS_P_8 PULLDOWN_N_R 0.06544f
C2466 HS_P_2 HS_N 0.46352f
C2467 PAD_P HS_N_2 1.25659f
C2468 FS_N_BLEED_4 HS_P 0.04811f
C2469 PULLUP_P_BLEED_5 TERM_OR_N_NS 0
C2470 HS_P_9 TERM_OR_P_B 0.1442f
C2471 HS_N_6 PULLUP_P_CONTROL_S 0.04808f
C2472 FS_P_OUT FS_P_WELL 0.18171p
C2473 FS_P_OUT VCM_LOW_OK 0.37711f
C2474 FS_P_BLEED_0 HS_N_12 0.06178f
C2475 DIV_ENABLE PULLUP_P_CONTROL_S 0.00795f
C2476 DIV_ENABLE HS_P 0.03818f
C2477 FS_P_BLEED_3 HS_N_13 0.02846f
C2478 HS_PBIAS PULLUP_P_OUT 0.55061f
C2479 FS_LOW_P HS_N_2 0.08505f
C2480 FS_P_OUT PAD_N 1.89403f
C2481 PULLUP_N_OUT PULLUP_P_BLEED_0 0.04637f
C2482 HS_N DIFF_ENABLE 0.3376f
C2483 PULLUP_P_BLEED_4 HS_N_0 0.05293f
C2484 PULLUP_P_WELL PULLUP_P_OUT 29.1254f
C2485 FS_P_BLEED_0 HS_N_1 0.06178f
C2486 TERM_VCM FS_HIGH_N 0.07041f
C2487 HS_N_7 HS_P_11 0
C2488 HS_N_8 HS_N_13 0.16699f
C2489 PULLUP_N_BLEED_3 PULLUP_N_BLEED_1 0.06528f
C2490 HS_P_2 PULLUP_P_OUT 0.06773f
C2491 PULLUP_N_BLEED_6 HS_PBIAS 0.04828f
C2492 HS_P_5 PULLDOWN_N_R 0.02411f
C2493 HS_P_10 TERM_VCM 0.13491f
C2494 FS_P_BLEED_1 FS_P_GATE 0.17756f
C2495 TERM_ENABLE TERM_P_R 0.46656f
C2496 PULLUP_P_WELL PULLUP_P_BLEED_2 0
C2497 PULLUP_P_BLEED_4 HS_N_2 0.0525f
C2498 FS_HIGH_N FS_N_BLEED_0 0.32903f
C2499 TERM_OR_P_NS VCM_LOW_OK 2.92628f
C2500 FS_P_BLEED_6 PULLUP_N_OUT 0.11535f
C2501 TERM_OR_N_NS PULLUP_N_OUT 0.05397f
C2502 PULLUP_N_OUT PULLUP_N_GATE 16.6062f
C2503 FS_P_BLEED_1 HS_N_10 0.03472f
C2504 HS_P_10 HS_P_1 37.0279f
C2505 PAD_P VDD 0
C2506 TERM_GATE_P TERM_P_R 26.175f
C2507 TERM_OR_N_S HS_N_9 0.03405f
C2508 a_42245_162628# ESD_RAIL 0.24367p
C2509 HS_N FS_P_BLEED_2 0.01113f
C2510 HS_N_7 TERM_GATE_N_BLEED_2 0.03702f
C2511 PULLUP_N_BLEED_6 DIFF_ENABLE 0.35616f
C2512 HS_N_0 HS_N_9 0.04157f
C2513 VDD PULLUP_N_BLEED_5 0.55431f
C2514 FS_LOW_P VDD 3.59076f
C2515 PAD_P DIV_N 0.45367f
C2516 TERM_VCM FS_N_BLEED_2 0.02041f
C2517 HS_P_3 FS_P_OUT 0.09146f
C2518 PULLUP_N_WELL PULLUP_N_BLEED_3 0
C2519 TERM_OR_P_B HS_N_10 0.0738f
C2520 HS_N_11 HS_P_5 0.03489f
C2521 VDD TERM_OR_P_S 4.39982f
C2522 FS_N_BLEED_1 PULLUP_N_WELL 0
C2523 FS_P_GATE FS_N_OUT 0.35576f
C2524 HS_N_5 PULLDOWN_P 0.04428f
C2525 DIV_N FS_LOW_P 6.0073f
C2526 PULLUP_N_OUT PULLUP_N_BLEED_1 0
C2527 HS_N_2 HS_N_9 0
C2528 FS_P_BLEED_2 PULLUP_P_OUT 0.00257f
C2529 FS_LOW_P FS_LOW_N 93.326f
C2530 PAD_P BYPASS_ENABLE 8.2284f
C2531 HS_P_11 PULLDOWN_N_R 0.07466f
C2532 FS_N_BLEED_2 FS_N_BLEED_0 0.12309f
C2533 PULLUP_P PULLUP_N 0.03743f
C2534 HS_P_7 HS_P_4 0.06067f
C2535 HS_N_3 HS_N 2.40305f
C2536 DIV_N PULLUP_P_BLEED_4 0
C2537 RX_N PAD_N 9.8031f
C2538 FS_P_BLEED_0 HS_N_5 0.06178f
C2539 FS_P_BLEED_1 TERM_P_R 0.04766f
C2540 HS_P_3 TERM_OR_P_NS 0.02846f
C2541 HS_N_7 TERM_GATE_N 0.05007f
C2542 TERM_OR_N_S VCM_LOW_OK 2.91765f
C2543 PULLDOWN_P PULLUP_N_BLEED_2 0.08014f
C2544 VDD FS_N_WELL 0.10242p
C2545 HS_N_0 VCM_LOW_OK 0.05893f
C2546 HS_N_0 FS_P_WELL 2.61482f
C2547 PULLUP_P_BLEED_3 PULLUP_P_BLEED_1 0.00855f
C2548 PULLUP_P_BLEED_4 FS_LOW_N 0.02437f
C2549 HS_N_8 HS_P_8 0.09066f
C2550 FS_HIGH_P TERM_ENABLE 0.01303f
C2551 FS_P_BLEED_0 HS_P 0.06178f
C2552 PULLUP_N_OUT FS_P_OUT 0.573f
C2553 HS_N_0 PAD_N 1.42664f
C2554 PULLDOWN_N PULLUP_N 0
C2555 HS_N_3 PULLUP_P_OUT 0.03489f
C2556 FS_LOW_N FS_N_WELL 0.8764f
C2557 TERM_GATE_N_BLEED_2 PULLDOWN_N_R 0.07928f
C2558 TERM_P_R TERM_OR_P_B 0.76857f
C2559 PULLUP_N_OUT PULLUP_N_WELL 30.7254f
C2560 TERM_GATE_P DIV_LOW_P 0.00428f
C2561 HS_N HS_P_0 0.54906f
C2562 HS_N_2 VCM_LOW_OK 0.05893f
C2563 HS_N_7 TERM_N_R 0.11615f
C2564 HS_N_2 FS_P_WELL 1.96621f
C2565 TERM_ENABLE HS_P_12 0.02404f
C2566 HS_P_11 HS_N_11 0.06806f
C2567 VDD HS_N_9 5.99389f
C2568 PULLUP_N_BLEED_4 TERM_N_R 0.05729f
C2569 FS_P_GATE HS_N_13 1.03609f
C2570 HS_N_2 PAD_N 1.16258f
C2571 FS_N_WELL BYPASS_ENABLE 0.05619f
C2572 TERM_P_R FS_N_OUT 0.3082f
C2573 RX_N VSS 40.3558f
C2574 RX_P VSS 39.629f
C2575 BYPASS_ENABLE VSS 60.4803f
C2576 HS_N VSS 56.645f
C2577 HS_P VSS 40.6501f
C2578 FS_LOW_P VSS 37.8589f
C2579 ATB_ESD_RAIL VSS 0.86326f
C2580 PAD_P VSS 0.40796p
C2581 PAD_N VSS 0.40351p
C2582 FS_HIGH_P VSS 8.4893f
C2583 PULLUP_P VSS 19.3017f
C2584 PULLDOWN_P VSS 14.1432f
C2585 FS_LOW_N VSS 8.18652f
C2586 TERM_ENABLE VSS 51.1634f
C2587 DIV_ENABLE VSS 22.9288f
C2588 TERM_VCM VSS 0.11336p
C2589 HS_PBIAS VSS 49.4032f
C2590 FS_HIGH_N VSS 4.29973f
C2591 PULLUP_N VSS 3.12827f
C2592 DIFF_ENABLE VSS 21.3625f
C2593 PULLDOWN_N VSS 4.99637f
C2594 ESD_RAIL VSS 1841.055664f
C2595 VDD VSS 0.72414p
C2596 m2_42279_196800# VSS 7.46506f $ **FLOATING
C2597 TERM_OR_P_S VSS 3.53275f
C2598 TERM_OR_P_NS VSS 10.0639f
C2599 TERM_GATE_P_BLEED_2 VSS 3.28565f
C2600 TERM_GATE_P_BLEED_1 VSS 5.10072f
C2601 TERM_GATE_P_BLEED_0 VSS 7.68181f
C2602 TERM_OR_P_B VSS 21.153f
C2603 TERM_GATE_P VSS 27.0289f
C2604 HS_P_4 VSS 7.08828f
C2605 HS_P_3 VSS 7.10742f
C2606 HS_P_2 VSS 6.92881f
C2607 HS_P_1 VSS 5.64833f
C2608 HS_P_0 VSS 7.04643f
C2609 DIV_LOW_P VSS 7.23693f
C2610 DIV_P VSS 14.1199f
C2611 HS_P_11 VSS 8.66739f
C2612 HS_P_10 VSS 6.56271f
C2613 HS_P_9 VSS 7.07185f
C2614 HS_P_8 VSS 5.6877f
C2615 HS_P_7 VSS 4.83643f
C2616 HS_P_6 VSS 5.96197f
C2617 HS_P_5 VSS 7.82827f
C2618 HS_P_13 VSS 6.1434f
C2619 HS_P_12 VSS 7.62117f
C2620 a_42245_162628# VSS 0.24984p
C2621 a_44789_189064# VSS 12.0947f
C2622 a_43813_189064# VSS 5.60447f
C2623 FS_P_BLEED_0 VSS 5.25478f
C2624 FS_P_CONTROL_S VSS 4.50476f
C2625 FS_P_OUT VSS 33.2921f
C2626 FS_P_GATE VSS 50.584f
C2627 FS_P_BLEED_6 VSS 4.71981f
C2628 FS_P_BLEED_5 VSS 4.09514f
C2629 FS_P_BLEED_4 VSS 3.52334f
C2630 FS_P_BLEED_3 VSS 3.16733f
C2631 FS_P_BLEED_2 VSS 3.71625f
C2632 FS_P_BLEED_1 VSS 8.07846f
C2633 PULLUP_P_OUT VSS 22.0369f
C2634 a_41005_203545# VSS 0.10822p
C2635 a_53878_203545# VSS 0.07835f
C2636 a_41005_203825# VSS 0.07377f
C2637 a_53878_204105# VSS 0.07394f
C2638 a_41005_204385# VSS 0.07377f
C2639 a_53878_204665# VSS 0.07394f
C2640 a_41005_204945# VSS 0.07377f
C2641 a_53878_205225# VSS 0.07394f
C2642 a_41005_205505# VSS 0.07377f
C2643 a_53878_205785# VSS 0.07394f
C2644 a_41005_206065# VSS 0.07377f
C2645 PULLUP_P_BLEED_2 VSS 4.21729f
C2646 PULLUP_P_BLEED_1 VSS 3.22052f
C2647 PULLUP_P_BLEED_0 VSS 3.1427f
C2648 PULLUP_P_CONTROL_S VSS 14.2222f
C2649 a_53878_206345# VSS 0.07838f
C2650 PULLDOWN_P_R VSS 21.8134f
C2651 PULLUP_P_GATE VSS 18.622f
C2652 PULLUP_P_BLEED_6 VSS 5.9721f
C2653 PULLUP_P_BLEED_5 VSS 8.83533f
C2654 PULLUP_P_BLEED_4 VSS 11.7853f
C2655 PULLUP_P_BLEED_3 VSS 8.31118f
C2656 TERM_OR_N_B VSS 9.20679f
C2657 TERM_OR_N_S VSS 8.30302f
C2658 TERM_OR_N_NS VSS 5.98425f
C2659 VCM_LOW_OK VSS 25.8594f
C2660 TERM_GATE_N_BLEED_2 VSS 14.3664f
C2661 TERM_GATE_N_BLEED_1 VSS 13.4026f
C2662 TERM_GATE_N_BLEED_0 VSS 8.30278f
C2663 HS_N_0 VSS 11.8194f
C2664 DIV_LOW_N VSS 8.79168f
C2665 DIV_N VSS 18.8798f
C2666 TERM_GATE_N VSS 18.495f
C2667 a_41684_220611# VSS 0.28621p
C2668 HS_N_7 VSS 9.28359f
C2669 HS_N_6 VSS 9.29898f
C2670 HS_N_5 VSS 8.48041f
C2671 HS_N_4 VSS 7.55183f
C2672 HS_N_3 VSS 7.91514f
C2673 HS_N_2 VSS 8.95462f
C2674 HS_N_1 VSS 9.59159f
C2675 HS_N_13 VSS 9.06212f
C2676 HS_N_12 VSS 9.99856f
C2677 HS_N_11 VSS 9.36849f
C2678 HS_N_10 VSS 9.03359f
C2679 HS_N_9 VSS 8.5391f
C2680 HS_N_8 VSS 9.00333f
C2681 a_41684_232275# VSS 1.50941p
C2682 FS_N_CONTROL_S VSS 6.67541f
C2683 FS_N_OUT VSS 66.0536f
C2684 FS_N_BLEED_3 VSS 5.83837f
C2685 FS_N_BLEED_2 VSS 4.75153f
C2686 FS_N_BLEED_1 VSS 4.13355f
C2687 FS_N_BLEED_0 VSS 3.57892f
C2688 FS_N_GATE VSS 51.325f
C2689 FS_N_BLEED_6 VSS 3.35184f
C2690 FS_N_BLEED_5 VSS 3.45768f
C2691 FS_N_BLEED_4 VSS 8.08501f
C2692 PULLUP_N_CONTROL_S VSS 4.4075f
C2693 PULLUP_N_OUT VSS 44.4719f
C2694 PULLUP_N_BLEED_5 VSS 4.51663f
C2695 PULLUP_N_BLEED_4 VSS 3.53996f
C2696 PULLUP_N_BLEED_3 VSS 2.95235f
C2697 PULLUP_N_BLEED_2 VSS 3.88779f
C2698 PULLUP_N_BLEED_1 VSS 6.69252f
C2699 PULLUP_N_BLEED_0 VSS 9.62445f
C2700 TERM_P_R VSS 90.0679f
C2701 TERM_N_R VSS 0.10882p
C2702 PULLDOWN_N_R VSS 36.526f
C2703 PULLUP_N_GATE VSS 18.208f
C2704 PULLUP_N_BLEED_6 VSS 8.22239f
C2705 FS_P_WELL VSS 0.43173p
C2706 PULLUP_P_WELL VSS 97.9489f
C2707 FS_N_WELL VSS 0.43833p
C2708 PULLUP_N_WELL VSS 0.10052p
DWELL_ARRAY VSS ESD_RAIL diode_nw2ps_06v0 area=569.4528p pj=470.72u
.ends

.lib /home/ubuntu/svalbard/scratch/transceiver-pad-pdk/ngspice/sm141064.ngspice diode_typical
.lib /home/ubuntu/svalbard/scratch/transceiver-pad-pdk/ngspice/sm141064.ngspice mimcap_typical
