.subckt tx_protected_pad PAD_P PAD_N VDD VSS TERM_VCM TERM_ENABLE DIFF_ENABLE DIV_ENABLE BYPASS_ENABLE RX_P RX_N HS_PBIAS HS_P HS_N FS_HIGH_P FS_HIGH_N FS_LOW_P FS_LOW_N PULLUP_P PULLUP_N PULLDOWN_P PULLDOWN_N ATB_ESD_RAIL
XPHYSICAL PAD_P PAD_N VDD VSS TERM_VCM TERM_ENABLE DIFF_ENABLE DIV_ENABLE BYPASS_ENABLE RX_P RX_N HS_PBIAS HS_P HS_N FS_HIGH_P FS_HIGH_N FS_LOW_P FS_LOW_N PULLUP_P PULLUP_N PULLDOWN_P PULLDOWN_N ESD_RAIL ATB_ESD_RAIL combined_flat
.ends tx_protected_pad
* NGSPICE file created from combined_flat.ext - technology: gf180mcuD

.subckt combined_flat PAD_P PAD_N VDD VSS TERM_VCM TERM_ENABLE DIFF_ENABLE DIV_ENABLE
+ BYPASS_ENABLE RX_P RX_N HS_PBIAS HS_P HS_N FS_HIGH_P FS_HIGH_N FS_LOW_P FS_LOW_N
+ PULLUP_P PULLUP_N PULLDOWN_P PULLDOWN_N ESD_RAIL ATB_ESD_RAIL
X0 VSS a_41764_160995# a_41764_160995# VSS nfet_06v0 ad=13.936p pd=54.12u as=13.936p ps=54.12u w=53.6u l=0.7u
X1 a_41764_160995# a_41764_148611# a_41764_148611# VSS nfet_06v0 ad=13.936p pd=54.12u as=13.936p ps=54.12u w=53.6u l=0.7u
X2 a_41764_160995# a_41764_148611# a_41764_148611# VSS nfet_06v0 ad=13.936p pd=54.12u as=13.936p ps=54.12u w=53.6u l=0.7u
X3 VSS a_42245_90628# ESD_RAIL VSS nfet_06v0 ad=13p pd=50.52u as=13p ps=50.52u w=50u l=0.7u
X4 a_41764_148611# ESD_RAIL ESD_RAIL VSS nfet_06v0 ad=13.936p pd=54.12u as=13.936p ps=54.12u w=53.6u l=0.7u
X5 VSS a_41764_160995# a_41764_160995# VSS nfet_06v0 ad=13.936p pd=54.12u as=13.936p ps=54.12u w=53.6u l=0.7u
X6 a_41764_148611# a_41764_148611# a_41764_160995# VSS nfet_06v0 ad=13.936p pd=54.12u as=23.584p ps=0.10808m w=53.6u l=0.7u
X7 ESD_RAIL ESD_RAIL a_41764_148611# VSS nfet_06v0 ad=13.936p pd=54.12u as=13.936p ps=54.12u w=53.6u l=0.7u
X8 FS_N_OUT FS_N_GATE FS_N_WELL FS_N_WELL pfet_03v3 ad=6.16p pd=28.88u as=6.16p ps=28.88u w=14u l=0.28u
X9 VSS a_41764_160995# a_41764_160995# VSS nfet_06v0 ad=13.936p pd=54.12u as=13.936p ps=54.12u w=53.6u l=0.7u
X10 VSS a_41764_160995# a_41764_160995# VSS nfet_06v0 ad=13.936p pd=54.12u as=13.936p ps=54.12u w=53.6u l=0.7u
X11 a_41764_148611# a_41764_148611# a_41764_160995# VSS nfet_06v0 ad=13.936p pd=54.12u as=13.936p ps=54.12u w=53.6u l=0.7u
X12 a_42245_90628# a_44789_117064# VSS VSS nfet_06v0 ad=1.3p pd=5.52u as=1.3p ps=5.52u w=5u l=0.7u
X13 ESD_RAIL a_44789_117064# a_42245_90628# ESD_RAIL pfet_06v0 ad=1.3p pd=5.52u as=1.3p ps=5.52u w=5u l=0.7u
X14 a_41764_148611# ESD_RAIL ESD_RAIL VSS nfet_06v0 ad=13.936p pd=54.12u as=13.936p ps=54.12u w=53.6u l=0.7u
X15 a_41764_148611# a_41764_148611# a_41764_160995# VSS nfet_06v0 ad=13.936p pd=54.12u as=23.584p ps=0.10808m w=53.6u l=0.7u
X16 TERM_P_R TERM_GATE_P TERM_VCM VSS nfet_03v3 ad=8.8p pd=40.88u as=8.8p ps=40.88u w=20u l=0.28u
X17 ESD_RAIL a_42245_90628# VSS VSS nfet_06v0 ad=13p pd=50.52u as=13p ps=50.52u w=50u l=0.7u
X18 a_42245_90628# a_44789_117064# ESD_RAIL ESD_RAIL pfet_06v0 ad=1.3p pd=5.52u as=1.3p ps=5.52u w=5u l=0.7u
X19 a_41764_160995# a_41764_148611# a_41764_148611# VSS nfet_06v0 ad=13.936p pd=54.12u as=13.936p ps=54.12u w=53.6u l=0.7u
X20 a_41764_160995# a_41764_148611# a_41764_148611# VSS nfet_06v0 ad=13.936p pd=54.12u as=13.936p ps=54.12u w=53.6u l=0.7u
X21 ESD_RAIL a_41005_131545# a_43813_117064# ESD_RAIL pfet_06v0 ad=1.3p pd=5.52u as=1.3p ps=5.52u w=5u l=0.7u
X22 HS_N_5 HS_N PAD_N VSS nfet_06v0 ad=8.8p pd=40.88u as=8.8p ps=40.88u w=20u l=0.7u
X23 VSS a_41764_160995# a_41764_160995# VSS nfet_06v0 ad=13.936p pd=54.12u as=13.936p ps=54.12u w=53.6u l=0.7u
X24 a_41764_160995# a_41764_148611# a_41764_148611# VSS nfet_06v0 ad=13.936p pd=54.12u as=13.936p ps=54.12u w=53.6u l=0.7u
X25 ESD_RAIL ESD_RAIL a_41764_148611# VSS nfet_06v0 ad=13.936p pd=54.12u as=13.936p ps=54.12u w=53.6u l=0.7u
X26 TERM_GATE_P TERM_GATE_P_BLEED_0 VSS ppolyf_u_1k r_width=1u r_length=12.5u
X27 FS_P_GATE FS_HIGH_P FS_P_WELL FS_P_WELL pfet_03v3 ad=1.76p pd=8.88u as=1.76p ps=8.88u w=4u l=0.28u
X28 VSS a_41764_160995# a_41764_160995# VSS nfet_06v0 ad=13.936p pd=54.12u as=13.936p ps=54.12u w=53.6u l=0.7u
X29 a_41764_160995# a_41764_148611# a_41764_148611# VSS nfet_06v0 ad=13.936p pd=54.12u as=13.936p ps=54.12u w=53.6u l=0.7u
X30 VSS a_41764_160995# a_41764_160995# VSS nfet_06v0 ad=13.936p pd=54.12u as=13.936p ps=54.12u w=53.6u l=0.7u
X31 a_41764_148611# ESD_RAIL ESD_RAIL VSS nfet_06v0 ad=13.936p pd=54.12u as=13.936p ps=54.12u w=53.6u l=0.7u
X32 a_41764_160995# a_41764_160995# VSS VSS nfet_06v0 ad=13.936p pd=54.12u as=13.936p ps=54.12u w=53.6u l=0.7u
X33 VSS a_41764_160995# a_41764_160995# VSS nfet_06v0 ad=13.936p pd=54.12u as=13.936p ps=54.12u w=53.6u l=0.7u
X34 a_41764_148611# a_41764_148611# a_41764_160995# VSS nfet_06v0 ad=13.936p pd=54.12u as=13.936p ps=54.12u w=53.6u l=0.7u
X35 ESD_RAIL ATB_ESD_RAIL VSS ppolyf_u_1k_6p0 r_width=1u r_length=0.47474m
X36 FS_P_CONTROL_S VDD VSS VSS nfet_03v3 ad=1.76p pd=8.88u as=1.76p ps=8.88u w=4u l=0.28u
X37 a_41764_148611# a_41764_148611# a_41764_160995# VSS nfet_06v0 ad=13.936p pd=54.12u as=13.936p ps=54.12u w=53.6u l=0.7u
X38 a_41764_160995# a_41764_160995# VSS VSS nfet_06v0 ad=13.936p pd=54.12u as=13.936p ps=54.12u w=53.6u l=0.7u
X39 a_41764_160995# a_41764_148611# a_41764_148611# VSS nfet_06v0 ad=13.936p pd=54.12u as=13.936p ps=54.12u w=53.6u l=0.7u
X40 ESD_RAIL ESD_RAIL a_41764_148611# VSS nfet_06v0 ad=13.936p pd=54.12u as=13.936p ps=54.12u w=53.6u l=0.7u
X41 ESD_RAIL a_42245_90628# VSS VSS nfet_06v0 ad=13p pd=50.52u as=13p ps=50.52u w=50u l=0.7u
X42 a_42245_90628# a_44789_117064# ESD_RAIL ESD_RAIL pfet_06v0 ad=1.3p pd=5.52u as=1.3p ps=5.52u w=5u l=0.7u
X43 ESD_RAIL ESD_RAIL a_41764_148611# VSS nfet_06v0 ad=13.936p pd=54.12u as=13.936p ps=54.12u w=53.6u l=0.7u
X44 HS_P_4 HS_PBIAS VDD VDD pfet_03v3 ad=8.8p pd=40.88u as=8.8p ps=40.88u w=20u l=1u
D0 VSS FS_HIGH_P diode_nd2ps_03v3 pj=5.76u area=2.0736p
X45 PULLUP_N_BLEED_6 PULLUP_N_GATE VSS ppolyf_u_1k r_width=1u r_length=12.5u
X46 TERM_N_R TERM_GATE_N TERM_VCM VSS nfet_03v3 ad=8.8p pd=40.88u as=8.8p ps=40.88u w=20u l=0.28u
X47 a_41764_148611# a_41764_148611# a_41764_160995# VSS nfet_06v0 ad=13.936p pd=54.12u as=23.584p ps=0.10808m w=53.6u l=0.7u
X48 a_41764_148611# a_41764_148611# a_41764_160995# VSS nfet_06v0 ad=13.936p pd=54.12u as=23.584p ps=0.10808m w=53.6u l=0.7u
X49 a_41764_148611# a_41764_148611# a_41764_160995# VSS nfet_06v0 ad=13.936p pd=54.12u as=13.936p ps=54.12u w=53.6u l=0.7u
X50 a_41764_148611# ESD_RAIL ESD_RAIL VSS nfet_06v0 ad=13.936p pd=54.12u as=13.936p ps=54.12u w=53.6u l=0.7u
X51 a_41764_148611# ESD_RAIL ESD_RAIL VSS nfet_06v0 ad=13.936p pd=54.12u as=13.936p ps=54.12u w=53.6u l=0.7u
X52 a_41764_160995# a_41764_160995# VSS VSS nfet_06v0 ad=13.936p pd=54.12u as=13.936p ps=54.12u w=53.6u l=0.7u
X53 a_41764_148611# ESD_RAIL ESD_RAIL VSS nfet_06v0 ad=13.936p pd=54.12u as=13.936p ps=54.12u w=53.6u l=0.7u
X54 PULLUP_P_CONTROL_S VDD VSS VSS nfet_03v3 ad=1.76p pd=8.88u as=1.76p ps=8.88u w=4u l=0.28u
X55 a_41764_160995# a_41764_160995# VSS VSS nfet_06v0 ad=13.936p pd=54.12u as=13.936p ps=54.12u w=53.6u l=0.7u
X56 a_41764_160995# a_41764_160995# VSS VSS nfet_06v0 ad=13.936p pd=54.12u as=13.936p ps=54.12u w=53.6u l=0.7u
X57 TERM_P_R TERM_GATE_P TERM_VCM VSS nfet_03v3 ad=8.8p pd=40.88u as=8.8p ps=40.88u w=20u l=0.28u
X58 ESD_RAIL a_42245_90628# VSS VSS nfet_06v0 ad=13p pd=50.52u as=13p ps=50.52u w=50u l=0.7u
X59 a_41764_160995# a_41764_160995# VSS VSS nfet_06v0 ad=13.936p pd=54.12u as=23.584p ps=0.10808m w=53.6u l=0.7u
X60 VDD FS_P_GATE FS_P_WELL FS_P_WELL pfet_03v3 ad=6.16p pd=28.88u as=6.16p ps=28.88u w=14u l=0.28u
X61 PULLUP_N_OUT PULLUP_N_GATE PULLUP_N_WELL PULLUP_N_WELL pfet_03v3 ad=8.8p pd=40.88u as=8.8p ps=40.88u w=20u l=0.28u
X62 TERM_N_R TERM_GATE_N TERM_VCM VSS nfet_03v3 ad=8.8p pd=40.88u as=8.8p ps=40.88u w=20u l=0.28u
X63 a_41764_160995# a_41764_160995# VSS VSS nfet_06v0 ad=13.936p pd=54.12u as=13.936p ps=54.12u w=53.6u l=0.7u
X64 a_41764_160995# a_41764_148611# a_41764_148611# VSS nfet_06v0 ad=23.584p pd=0.10808m as=13.936p ps=54.12u w=53.6u l=0.7u
X65 HS_N_4 HS_N PAD_N VSS nfet_06v0 ad=8.8p pd=40.88u as=8.8p ps=40.88u w=20u l=0.7u
X66 VSS a_41764_160995# a_41764_160995# VSS nfet_06v0 ad=13.936p pd=54.12u as=13.936p ps=54.12u w=53.6u l=0.7u
X67 ESD_RAIL a_42245_90628# VSS VSS nfet_06v0 ad=13p pd=50.52u as=13p ps=50.52u w=50u l=0.7u
X68 VDD FS_P_GATE FS_P_WELL FS_P_WELL pfet_03v3 ad=6.16p pd=28.88u as=6.16p ps=28.88u w=14u l=0.28u
X69 PULLUP_N_OUT PULLUP_N_GATE PULLUP_N_WELL PULLUP_N_WELL pfet_03v3 ad=8.8p pd=40.88u as=8.8p ps=40.88u w=20u l=0.28u
X70 VDD FS_N_GATE FS_N_WELL FS_N_WELL pfet_03v3 ad=6.16p pd=28.88u as=6.16p ps=28.88u w=14u l=0.28u
X71 a_41764_148611# a_41764_148611# a_41764_160995# VSS nfet_06v0 ad=13.936p pd=54.12u as=13.936p ps=54.12u w=53.6u l=0.7u
X72 VSS a_41764_160995# a_41764_160995# VSS nfet_06v0 ad=13.936p pd=54.12u as=13.936p ps=54.12u w=53.6u l=0.7u
D1 PAD_N ESD_RAIL diode_pd2nw_06v0 pj=51.8u area=22.5p
X73 FS_N_GATE VDD FS_N_WELL FS_N_WELL pfet_03v3 ad=1.76p pd=8.88u as=1.76p ps=8.88u w=4u l=0.28u
X74 a_41764_160995# a_41764_160995# VSS VSS nfet_06v0 ad=13.936p pd=54.12u as=13.936p ps=54.12u w=53.6u l=0.7u
X75 VDD FS_N_GATE FS_N_WELL FS_N_WELL pfet_03v3 ad=6.16p pd=28.88u as=6.16p ps=28.88u w=14u l=0.28u
X76 FS_P_OUT FS_P_GATE FS_P_WELL FS_P_WELL pfet_03v3 ad=6.16p pd=28.88u as=6.16p ps=28.88u w=14u l=0.28u
X77 a_41764_160995# a_41764_148611# a_41764_148611# VSS nfet_06v0 ad=13.936p pd=54.12u as=13.936p ps=54.12u w=53.6u l=0.7u
X78 ESD_RAIL ESD_RAIL a_41764_148611# VSS nfet_06v0 ad=13.936p pd=54.12u as=13.936p ps=54.12u w=53.6u l=0.7u
X79 TERM_OR_N_S TERM_ENABLE VDD VDD pfet_03v3 ad=1.76p pd=8.88u as=1.76p ps=8.88u w=4u l=0.28u
X80 VSS a_41764_160995# a_41764_160995# VSS nfet_06v0 ad=13.936p pd=54.12u as=13.936p ps=54.12u w=53.6u l=0.7u
X81 a_41005_131825# a_53878_132105# ESD_RAIL ppolyf_u r_width=0.8u r_length=63.855u
X82 a_41764_148611# ESD_RAIL ESD_RAIL VSS nfet_06v0 ad=23.584p pd=0.10808m as=13.936p ps=54.12u w=53.6u l=0.7u
X83 ESD_RAIL ESD_RAIL a_41764_148611# VSS nfet_06v0 ad=13.936p pd=54.12u as=13.936p ps=54.12u w=53.6u l=0.7u
X84 PULLUP_P_BLEED_1 PULLUP_P_BLEED_2 VSS ppolyf_u_1k r_width=1u r_length=12.5u
X85 a_41764_148611# a_41764_148611# a_41764_160995# VSS nfet_06v0 ad=13.936p pd=54.12u as=23.584p ps=0.10808m w=53.6u l=0.7u
X86 a_41764_160995# a_41764_148611# a_41764_148611# VSS nfet_06v0 ad=13.936p pd=54.12u as=13.936p ps=54.12u w=53.6u l=0.7u
X87 a_41005_131545# VSS cap_mim_2f0_m4m5_noshield c_width=31.6u c_length=31.6u
X88 a_41764_148611# ESD_RAIL ESD_RAIL VSS nfet_06v0 ad=13.936p pd=54.12u as=13.936p ps=54.12u w=53.6u l=0.7u
X89 ESD_RAIL a_42245_90628# VSS VSS nfet_06v0 ad=13p pd=50.52u as=13p ps=50.52u w=50u l=0.7u
X90 a_41764_160995# a_41764_148611# a_41764_148611# VSS nfet_06v0 ad=13.936p pd=54.12u as=13.936p ps=54.12u w=53.6u l=0.7u
X91 a_41764_148611# a_41764_148611# a_41764_160995# VSS nfet_06v0 ad=13.936p pd=54.12u as=13.936p ps=54.12u w=53.6u l=0.7u
X92 a_41764_160995# a_41764_160995# VSS VSS nfet_06v0 ad=13.936p pd=54.12u as=13.936p ps=54.12u w=53.6u l=0.7u
X93 a_41764_160995# a_41764_148611# a_41764_148611# VSS nfet_06v0 ad=13.936p pd=54.12u as=13.936p ps=54.12u w=53.6u l=0.7u
X94 ESD_RAIL ESD_RAIL a_41764_148611# VSS nfet_06v0 ad=13.936p pd=54.12u as=13.936p ps=54.12u w=53.6u l=0.7u
X95 a_42245_90628# a_44789_117064# ESD_RAIL ESD_RAIL pfet_06v0 ad=1.3p pd=5.52u as=1.3p ps=5.52u w=5u l=0.7u
X96 PULLDOWN_P_R PULLDOWN_P VSS VSS nfet_03v3 ad=3.52p pd=16.88u as=3.52p ps=16.88u w=8u l=0.28u
X97 VSS a_41764_160995# a_41764_160995# VSS nfet_06v0 ad=13.936p pd=54.12u as=13.936p ps=54.12u w=53.6u l=0.7u
X98 a_41764_160995# a_41764_160995# VSS VSS nfet_06v0 ad=13.936p pd=54.12u as=13.936p ps=54.12u w=53.6u l=0.7u
X99 a_41764_148611# a_41764_148611# a_41764_160995# VSS nfet_06v0 ad=13.936p pd=54.12u as=13.936p ps=54.12u w=53.6u l=0.7u
X100 VSS a_41764_160995# a_41764_160995# VSS nfet_06v0 ad=13.936p pd=54.12u as=13.936p ps=54.12u w=53.6u l=0.7u
X101 VSS a_42245_90628# ESD_RAIL VSS nfet_06v0 ad=13p pd=50.52u as=13p ps=50.52u w=50u l=0.7u
X102 ESD_RAIL a_42245_90628# VSS VSS nfet_06v0 ad=13p pd=50.52u as=13p ps=50.52u w=50u l=0.7u
X103 a_41764_148611# a_41764_148611# a_41764_160995# VSS nfet_06v0 ad=13.936p pd=54.12u as=13.936p ps=54.12u w=53.6u l=0.7u
X104 a_41764_148611# a_41764_148611# a_41764_160995# VSS nfet_06v0 ad=13.936p pd=54.12u as=13.936p ps=54.12u w=53.6u l=0.7u
X105 a_41764_160995# a_41764_160995# VSS VSS nfet_06v0 ad=13.936p pd=54.12u as=13.936p ps=54.12u w=53.6u l=0.7u
X106 a_41764_148611# a_41764_148611# a_41764_160995# VSS nfet_06v0 ad=13.936p pd=54.12u as=13.936p ps=54.12u w=53.6u l=0.7u
X107 ESD_RAIL a_44789_117064# a_42245_90628# ESD_RAIL pfet_06v0 ad=1.3p pd=5.52u as=1.3p ps=5.52u w=5u l=0.7u
X108 a_42245_90628# a_44789_117064# ESD_RAIL ESD_RAIL pfet_06v0 ad=1.3p pd=5.52u as=1.3p ps=5.52u w=5u l=0.7u
X109 a_41764_160995# a_41764_160995# VSS VSS nfet_06v0 ad=13.936p pd=54.12u as=13.936p ps=54.12u w=53.6u l=0.7u
X110 a_41764_160995# a_41764_148611# a_41764_148611# VSS nfet_06v0 ad=13.936p pd=54.12u as=13.936p ps=54.12u w=53.6u l=0.7u
D2 PAD_P ESD_RAIL diode_pd2nw_06v0 pj=51.8u area=22.5p
X111 VSS a_44789_117064# a_42245_90628# VSS nfet_06v0 ad=2.2p pd=10.88u as=1.3p ps=5.52u w=5u l=0.7u
X112 FS_P_OUT FS_P_GATE FS_P_WELL FS_P_WELL pfet_03v3 ad=6.16p pd=28.88u as=6.16p ps=28.88u w=14u l=0.28u
X113 VSS a_41764_160995# a_41764_160995# VSS nfet_06v0 ad=13.936p pd=54.12u as=13.936p ps=54.12u w=53.6u l=0.7u
X114 a_41764_148611# a_41764_148611# a_41764_160995# VSS nfet_06v0 ad=13.936p pd=54.12u as=23.584p ps=0.10808m w=53.6u l=0.7u
X115 a_41764_148611# ESD_RAIL ESD_RAIL VSS nfet_06v0 ad=13.936p pd=54.12u as=13.936p ps=54.12u w=53.6u l=0.7u
X116 ESD_RAIL ESD_RAIL a_41764_148611# VSS nfet_06v0 ad=13.936p pd=54.12u as=13.936p ps=54.12u w=53.6u l=0.7u
X117 ESD_RAIL a_42245_90628# VSS VSS nfet_06v0 ad=13p pd=50.52u as=13p ps=50.52u w=50u l=0.7u
X118 ESD_RAIL ESD_RAIL a_41764_148611# VSS nfet_06v0 ad=13.936p pd=54.12u as=13.936p ps=54.12u w=53.6u l=0.7u
X119 a_41764_148611# ESD_RAIL ESD_RAIL VSS nfet_06v0 ad=13.936p pd=54.12u as=13.936p ps=54.12u w=53.6u l=0.7u
X120 ESD_RAIL a_44789_117064# a_42245_90628# ESD_RAIL pfet_06v0 ad=1.3p pd=5.52u as=1.3p ps=5.52u w=5u l=0.7u
X121 a_41764_148611# a_41764_148611# a_41764_160995# VSS nfet_06v0 ad=13.936p pd=54.12u as=13.936p ps=54.12u w=53.6u l=0.7u
X122 ESD_RAIL a_42245_90628# VSS VSS nfet_06v0 ad=22p pd=0.10088m as=13p ps=50.52u w=50u l=0.7u
X123 VSS a_42245_90628# ESD_RAIL VSS nfet_06v0 ad=13p pd=50.52u as=13p ps=50.52u w=50u l=0.7u
X124 HS_P_9 HS_PBIAS VDD VDD pfet_03v3 ad=8.8p pd=40.88u as=8.8p ps=40.88u w=20u l=1u
X125 a_41764_160995# a_41764_160995# VSS VSS nfet_06v0 ad=13.936p pd=54.12u as=13.936p ps=54.12u w=53.6u l=0.7u
X126 a_41764_148611# a_41764_148611# a_41764_160995# VSS nfet_06v0 ad=13.936p pd=54.12u as=13.936p ps=54.12u w=53.6u l=0.7u
X127 a_41005_132945# a_53878_133225# ESD_RAIL ppolyf_u r_width=0.8u r_length=63.855u
X128 a_41764_160995# a_41764_148611# a_41764_148611# VSS nfet_06v0 ad=13.936p pd=54.12u as=13.936p ps=54.12u w=53.6u l=0.7u
X129 a_41764_160995# a_41764_148611# a_41764_148611# VSS nfet_06v0 ad=13.936p pd=54.12u as=13.936p ps=54.12u w=53.6u l=0.7u
X130 a_41764_160995# a_41764_148611# a_41764_148611# VSS nfet_06v0 ad=13.936p pd=54.12u as=13.936p ps=54.12u w=53.6u l=0.7u
X131 a_41764_160995# a_41764_148611# a_41764_148611# VSS nfet_06v0 ad=13.936p pd=54.12u as=13.936p ps=54.12u w=53.6u l=0.7u
X132 ESD_RAIL ESD_RAIL a_41764_148611# VSS nfet_06v0 ad=13.936p pd=54.12u as=13.936p ps=54.12u w=53.6u l=0.7u
X133 VSS a_41764_160995# a_41764_160995# VSS nfet_06v0 ad=13.936p pd=54.12u as=13.936p ps=54.12u w=53.6u l=0.7u
X134 a_42245_90628# a_44789_117064# VSS VSS nfet_06v0 ad=1.3p pd=5.52u as=1.3p ps=5.52u w=5u l=0.7u
X135 ESD_RAIL a_44789_117064# a_42245_90628# ESD_RAIL pfet_06v0 ad=1.3p pd=5.52u as=1.3p ps=5.52u w=5u l=0.7u
X136 VSS a_41764_160995# a_41764_160995# VSS nfet_06v0 ad=13.936p pd=54.12u as=13.936p ps=54.12u w=53.6u l=0.7u
X137 VSS a_41764_160995# a_41764_160995# VSS nfet_06v0 ad=23.584p pd=0.10808m as=13.936p ps=54.12u w=53.6u l=0.7u
X138 FS_P_OUT FS_P_GATE FS_P_WELL FS_P_WELL pfet_03v3 ad=6.16p pd=28.88u as=6.16p ps=28.88u w=14u l=0.28u
X139 VDD FS_N_GATE FS_N_WELL FS_N_WELL pfet_03v3 ad=6.16p pd=28.88u as=6.16p ps=28.88u w=14u l=0.28u
X140 HS_N_9 HS_N PAD_N VSS nfet_06v0 ad=8.8p pd=40.88u as=8.8p ps=40.88u w=20u l=0.7u
X141 a_41764_148611# ESD_RAIL ESD_RAIL VSS nfet_06v0 ad=13.936p pd=54.12u as=13.936p ps=54.12u w=53.6u l=0.7u
X142 ESD_RAIL ESD_RAIL a_41764_148611# VSS nfet_06v0 ad=13.936p pd=54.12u as=13.936p ps=54.12u w=53.6u l=0.7u
X143 ESD_RAIL ESD_RAIL a_41764_148611# VSS nfet_06v0 ad=13.936p pd=54.12u as=13.936p ps=54.12u w=53.6u l=0.7u
X144 a_41764_148611# ESD_RAIL ESD_RAIL VSS nfet_06v0 ad=23.584p pd=0.10808m as=13.936p ps=54.12u w=53.6u l=0.7u
X145 a_42245_90628# a_44789_117064# ESD_RAIL ESD_RAIL pfet_06v0 ad=1.3p pd=5.52u as=2.2p ps=10.88u w=5u l=0.7u
X146 ESD_RAIL ESD_RAIL a_41764_148611# VSS nfet_06v0 ad=13.936p pd=54.12u as=13.936p ps=54.12u w=53.6u l=0.7u
X147 a_41764_160995# a_41764_160995# VSS VSS nfet_06v0 ad=13.936p pd=54.12u as=13.936p ps=54.12u w=53.6u l=0.7u
X148 a_41764_160995# a_41764_160995# VSS VSS nfet_06v0 ad=13.936p pd=54.12u as=13.936p ps=54.12u w=53.6u l=0.7u
X149 a_41764_160995# a_41764_148611# a_41764_148611# VSS nfet_06v0 ad=13.936p pd=54.12u as=13.936p ps=54.12u w=53.6u l=0.7u
X150 FS_P_OUT FS_P_GATE FS_P_WELL FS_P_WELL pfet_03v3 ad=6.16p pd=28.88u as=6.16p ps=28.88u w=14u l=0.28u
X151 a_43813_117064# a_41005_131545# VSS VSS nfet_06v0 ad=2.2p pd=10.88u as=2.2p ps=10.88u w=5u l=0.7u
X152 a_41764_160995# a_41764_148611# a_41764_148611# VSS nfet_06v0 ad=13.936p pd=54.12u as=13.936p ps=54.12u w=53.6u l=0.7u
X153 VSS a_41764_160995# a_41764_160995# VSS nfet_06v0 ad=13.936p pd=54.12u as=13.936p ps=54.12u w=53.6u l=0.7u
X154 a_41764_160995# a_41764_148611# a_41764_148611# VSS nfet_06v0 ad=13.936p pd=54.12u as=13.936p ps=54.12u w=53.6u l=0.7u
X155 a_41764_148611# ESD_RAIL ESD_RAIL VSS nfet_06v0 ad=13.936p pd=54.12u as=13.936p ps=54.12u w=53.6u l=0.7u
X156 a_41764_148611# a_41764_148611# a_41764_160995# VSS nfet_06v0 ad=13.936p pd=54.12u as=13.936p ps=54.12u w=53.6u l=0.7u
X157 a_41764_160995# a_41764_148611# a_41764_148611# VSS nfet_06v0 ad=13.936p pd=54.12u as=13.936p ps=54.12u w=53.6u l=0.7u
X158 a_41764_148611# ESD_RAIL ESD_RAIL VSS nfet_06v0 ad=13.936p pd=54.12u as=13.936p ps=54.12u w=53.6u l=0.7u
X159 a_41764_160995# a_41764_160995# VSS VSS nfet_06v0 ad=13.936p pd=54.12u as=23.584p ps=0.10808m w=53.6u l=0.7u
X160 a_41764_148611# a_41764_148611# a_41764_160995# VSS nfet_06v0 ad=13.936p pd=54.12u as=13.936p ps=54.12u w=53.6u l=0.7u
X161 ESD_RAIL a_42245_90628# VSS VSS nfet_06v0 ad=13p pd=50.52u as=13p ps=50.52u w=50u l=0.7u
X162 VSS a_42245_90628# ESD_RAIL VSS nfet_06v0 ad=13p pd=50.52u as=22p ps=0.10088m w=50u l=0.7u
X163 a_42245_90628# a_44789_117064# VSS VSS nfet_06v0 ad=1.3p pd=5.52u as=1.3p ps=5.52u w=5u l=0.7u
X164 a_41764_148611# ESD_RAIL ESD_RAIL VSS nfet_06v0 ad=13.936p pd=54.12u as=13.936p ps=54.12u w=53.6u l=0.7u
X165 HS_P_7 HS_PBIAS VDD VDD pfet_03v3 ad=8.8p pd=40.88u as=8.8p ps=40.88u w=20u l=1u
X166 a_41764_148611# ESD_RAIL ESD_RAIL VSS nfet_06v0 ad=13.936p pd=54.12u as=13.936p ps=54.12u w=53.6u l=0.7u
X167 ESD_RAIL ESD_RAIL a_41764_148611# VSS nfet_06v0 ad=13.936p pd=54.12u as=13.936p ps=54.12u w=53.6u l=0.7u
X168 a_41764_160995# a_41764_160995# VSS VSS nfet_06v0 ad=13.936p pd=54.12u as=13.936p ps=54.12u w=53.6u l=0.7u
X169 a_41764_160995# a_41764_160995# VSS VSS nfet_06v0 ad=13.936p pd=54.12u as=13.936p ps=54.12u w=53.6u l=0.7u
X170 VSS a_43813_117064# a_44789_117064# VSS nfet_06v0 ad=1.3p pd=5.52u as=1.3p ps=5.52u w=5u l=0.7u
X171 a_42245_90628# a_44789_117064# ESD_RAIL ESD_RAIL pfet_06v0 ad=1.3p pd=5.52u as=1.3p ps=5.52u w=5u l=0.7u
X172 HS_P_11 HS_P PAD_P VSS nfet_06v0 ad=8.8p pd=40.88u as=8.8p ps=40.88u w=20u l=0.7u
X173 VSS a_42245_90628# ESD_RAIL VSS nfet_06v0 ad=13p pd=50.52u as=22p ps=0.10088m w=50u l=0.7u
X174 PAD_P PULLDOWN_P_R VSS ppolyf_u_1k r_width=1u r_length=14.2u
X175 TERM_P_R TERM_GATE_P TERM_VCM VSS nfet_03v3 ad=8.8p pd=40.88u as=8.8p ps=40.88u w=20u l=0.28u
X176 VSS a_41764_160995# a_41764_160995# VSS nfet_06v0 ad=13.936p pd=54.12u as=13.936p ps=54.12u w=53.6u l=0.7u
X177 VSS a_41764_160995# a_41764_160995# VSS nfet_06v0 ad=13.936p pd=54.12u as=13.936p ps=54.12u w=53.6u l=0.7u
X178 VSS a_41764_160995# a_41764_160995# VSS nfet_06v0 ad=23.584p pd=0.10808m as=13.936p ps=54.12u w=53.6u l=0.7u
X179 a_41764_148611# a_41764_148611# a_41764_160995# VSS nfet_06v0 ad=13.936p pd=54.12u as=13.936p ps=54.12u w=53.6u l=0.7u
X180 PAD_P BYPASS_ENABLE RX_P VSS nfet_06v0 ad=8.8p pd=40.88u as=8.8p ps=40.88u w=20u l=0.7u
X181 a_41764_148611# a_41764_148611# a_41764_160995# VSS nfet_06v0 ad=13.936p pd=54.12u as=13.936p ps=54.12u w=53.6u l=0.7u
X182 a_41764_148611# a_41764_148611# a_41764_160995# VSS nfet_06v0 ad=13.936p pd=54.12u as=13.936p ps=54.12u w=53.6u l=0.7u
X183 HS_N_6 HS_N PAD_N VSS nfet_06v0 ad=8.8p pd=40.88u as=8.8p ps=40.88u w=20u l=0.7u
X184 a_41005_134065# a_53878_134345# ESD_RAIL ppolyf_u r_width=0.8u r_length=63.855u
X185 a_41764_148611# ESD_RAIL ESD_RAIL VSS nfet_06v0 ad=23.584p pd=0.10808m as=13.936p ps=54.12u w=53.6u l=0.7u
X186 a_41764_160995# a_41764_160995# VSS VSS nfet_06v0 ad=13.936p pd=54.12u as=13.936p ps=54.12u w=53.6u l=0.7u
X187 VDD FS_N_GATE FS_N_WELL FS_N_WELL pfet_03v3 ad=6.16p pd=28.88u as=6.16p ps=28.88u w=14u l=0.28u
X188 FS_P_OUT FS_P_GATE FS_P_WELL FS_P_WELL pfet_03v3 ad=6.16p pd=28.88u as=6.16p ps=28.88u w=14u l=0.28u
X189 a_41764_148611# a_41764_148611# a_41764_160995# VSS nfet_06v0 ad=13.936p pd=54.12u as=23.584p ps=0.10808m w=53.6u l=0.7u
D3 PAD_N ESD_RAIL diode_pd2nw_06v0 pj=51.8u area=22.5p
X190 ESD_RAIL ESD_RAIL a_41764_148611# VSS nfet_06v0 ad=13.936p pd=54.12u as=13.936p ps=54.12u w=53.6u l=0.7u
X191 a_41764_148611# a_41764_148611# a_41764_160995# VSS nfet_06v0 ad=13.936p pd=54.12u as=13.936p ps=54.12u w=53.6u l=0.7u
X192 ESD_RAIL a_42245_90628# VSS VSS nfet_06v0 ad=13p pd=50.52u as=13p ps=50.52u w=50u l=0.7u
X193 DIV_LOW_P DIV_ENABLE VSS VSS nfet_03v3 ad=8.8p pd=40.88u as=8.8p ps=40.88u w=20u l=0.28u
X194 ESD_RAIL ESD_RAIL a_41764_148611# VSS nfet_06v0 ad=13.936p pd=54.12u as=13.936p ps=54.12u w=53.6u l=0.7u
X195 a_41764_160995# a_41764_148611# a_41764_148611# VSS nfet_06v0 ad=13.936p pd=54.12u as=13.936p ps=54.12u w=53.6u l=0.7u
X196 VDD FS_N_GATE FS_N_WELL FS_N_WELL pfet_03v3 ad=6.16p pd=28.88u as=6.16p ps=28.88u w=14u l=0.28u
X197 FS_P_OUT FS_P_GATE FS_P_WELL FS_P_WELL pfet_03v3 ad=6.16p pd=28.88u as=6.16p ps=28.88u w=14u l=0.28u
X198 VSS a_43813_117064# a_44789_117064# VSS nfet_06v0 ad=1.3p pd=5.52u as=1.3p ps=5.52u w=5u l=0.7u
X199 ESD_RAIL ESD_RAIL a_41764_148611# VSS nfet_06v0 ad=13.936p pd=54.12u as=23.584p ps=0.10808m w=53.6u l=0.7u
D4 PAD_P ESD_RAIL diode_pd2nw_06v0 pj=51.8u area=22.5p
X200 HS_N_7 HS_N PAD_N VSS nfet_06v0 ad=8.8p pd=40.88u as=8.8p ps=40.88u w=20u l=0.7u
X201 FS_P_BLEED_6 FS_P_GATE VSS ppolyf_u_1k r_width=1u r_length=12.5u
X202 a_41764_160995# a_41764_148611# a_41764_148611# VSS nfet_06v0 ad=13.936p pd=54.12u as=13.936p ps=54.12u w=53.6u l=0.7u
X203 VSS a_42245_90628# ESD_RAIL VSS nfet_06v0 ad=13p pd=50.52u as=13p ps=50.52u w=50u l=0.7u
X204 a_41764_148611# a_41764_148611# a_41764_160995# VSS nfet_06v0 ad=13.936p pd=54.12u as=13.936p ps=54.12u w=53.6u l=0.7u
X205 VDD PULLUP_P_GATE PULLUP_P_WELL PULLUP_P_WELL pfet_03v3 ad=8.8p pd=40.88u as=8.8p ps=40.88u w=20u l=0.28u
X206 FS_P_OUT FS_P_GATE FS_P_WELL FS_P_WELL pfet_03v3 ad=6.16p pd=28.88u as=6.16p ps=28.88u w=14u l=0.28u
X207 ESD_RAIL a_42245_90628# VSS VSS nfet_06v0 ad=13p pd=50.52u as=13p ps=50.52u w=50u l=0.7u
X208 a_41764_148611# ESD_RAIL ESD_RAIL VSS nfet_06v0 ad=13.936p pd=54.12u as=13.936p ps=54.12u w=53.6u l=0.7u
X209 a_41764_160995# a_41764_160995# VSS VSS nfet_06v0 ad=13.936p pd=54.12u as=13.936p ps=54.12u w=53.6u l=0.7u
X210 TERM_P_R DIFF_ENABLE TERM_N_R VSS nfet_03v3 ad=8.8p pd=40.88u as=8.8p ps=40.88u w=20u l=0.28u
X211 a_41764_160995# a_41764_160995# VSS VSS nfet_06v0 ad=13.936p pd=54.12u as=13.936p ps=54.12u w=53.6u l=0.7u
X212 a_41764_160995# a_41764_148611# a_41764_148611# VSS nfet_06v0 ad=13.936p pd=54.12u as=13.936p ps=54.12u w=53.6u l=0.7u
X213 ESD_RAIL ESD_RAIL a_41764_148611# VSS nfet_06v0 ad=13.936p pd=54.12u as=13.936p ps=54.12u w=53.6u l=0.7u
X214 ESD_RAIL ESD_RAIL a_41764_148611# VSS nfet_06v0 ad=13.936p pd=54.12u as=13.936p ps=54.12u w=53.6u l=0.7u
X215 VDD FS_N_GATE FS_N_WELL FS_N_WELL pfet_03v3 ad=6.16p pd=28.88u as=6.16p ps=28.88u w=14u l=0.28u
D5 VSS TERM_ENABLE diode_nd2ps_03v3 pj=7.56u area=3.5721p
X216 TERM_OR_N_B TERM_ENABLE VSS VSS nfet_03v3 ad=0.88p pd=4.88u as=0.88p ps=4.88u w=2u l=0.28u
X217 VSS a_41764_160995# a_41764_160995# VSS nfet_06v0 ad=13.936p pd=54.12u as=13.936p ps=54.12u w=53.6u l=0.7u
X218 HS_N_2 HS_N PAD_N VSS nfet_06v0 ad=8.8p pd=40.88u as=8.8p ps=40.88u w=20u l=0.7u
X219 a_41764_148611# ESD_RAIL ESD_RAIL VSS nfet_06v0 ad=13.936p pd=54.12u as=13.936p ps=54.12u w=53.6u l=0.7u
X220 ESD_RAIL a_42245_90628# VSS VSS nfet_06v0 ad=13p pd=50.52u as=13p ps=50.52u w=50u l=0.7u
X221 VSS a_41764_160995# a_41764_160995# VSS nfet_06v0 ad=13.936p pd=54.12u as=13.936p ps=54.12u w=53.6u l=0.7u
X222 VSS a_41764_160995# a_41764_160995# VSS nfet_06v0 ad=13.936p pd=54.12u as=13.936p ps=54.12u w=53.6u l=0.7u
X223 a_41764_148611# a_41764_148611# a_41764_160995# VSS nfet_06v0 ad=13.936p pd=54.12u as=13.936p ps=54.12u w=53.6u l=0.7u
X224 HS_N_6 HS_PBIAS VDD VDD pfet_03v3 ad=8.8p pd=40.88u as=8.8p ps=40.88u w=20u l=1u
X225 a_41764_160995# a_41764_160995# VSS VSS nfet_06v0 ad=13.936p pd=54.12u as=13.936p ps=54.12u w=53.6u l=0.7u
X226 PULLUP_N_OUT PULLUP_N_GATE PULLUP_N_WELL PULLUP_N_WELL pfet_03v3 ad=8.8p pd=40.88u as=8.8p ps=40.88u w=20u l=0.28u
X227 a_41764_148611# a_41764_148611# a_41764_160995# VSS nfet_06v0 ad=13.936p pd=54.12u as=13.936p ps=54.12u w=53.6u l=0.7u
X228 a_41764_160995# a_41764_160995# VSS VSS nfet_06v0 ad=13.936p pd=54.12u as=13.936p ps=54.12u w=53.6u l=0.7u
X229 a_41764_160995# a_41764_148611# a_41764_148611# VSS nfet_06v0 ad=13.936p pd=54.12u as=13.936p ps=54.12u w=53.6u l=0.7u
X230 a_41764_148611# ESD_RAIL ESD_RAIL VSS nfet_06v0 ad=13.936p pd=54.12u as=13.936p ps=54.12u w=53.6u l=0.7u
X231 HS_N_8 HS_PBIAS VDD VDD pfet_03v3 ad=8.8p pd=40.88u as=8.8p ps=40.88u w=20u l=1u
X232 FS_P_BLEED_0 FS_P_BLEED_1 VSS ppolyf_u_1k r_width=1u r_length=12.5u
X233 a_41764_160995# a_41764_148611# a_41764_148611# VSS nfet_06v0 ad=13.936p pd=54.12u as=13.936p ps=54.12u w=53.6u l=0.7u
X234 PULLUP_N_BLEED_3 PULLUP_N_BLEED_4 VSS ppolyf_u_1k r_width=1u r_length=12.5u
X235 FS_P_OUT FS_P_GATE FS_P_WELL FS_P_WELL pfet_03v3 ad=6.16p pd=28.88u as=6.16p ps=28.88u w=14u l=0.28u
X236 FS_N_OUT PAD_N VSS ppolyf_s r_width=2u r_length=3.5u
X237 a_41764_148611# ESD_RAIL ESD_RAIL VSS nfet_06v0 ad=13.936p pd=54.12u as=13.936p ps=54.12u w=53.6u l=0.7u
X238 VSS a_41764_160995# a_41764_160995# VSS nfet_06v0 ad=13.936p pd=54.12u as=13.936p ps=54.12u w=53.6u l=0.7u
X239 a_41764_148611# a_41764_148611# a_41764_160995# VSS nfet_06v0 ad=13.936p pd=54.12u as=13.936p ps=54.12u w=53.6u l=0.7u
X240 a_41764_148611# a_41764_148611# a_41764_160995# VSS nfet_06v0 ad=13.936p pd=54.12u as=13.936p ps=54.12u w=53.6u l=0.7u
X241 a_41764_160995# a_41764_148611# a_41764_148611# VSS nfet_06v0 ad=13.936p pd=54.12u as=13.936p ps=54.12u w=53.6u l=0.7u
X242 ESD_RAIL ESD_RAIL a_41764_148611# VSS nfet_06v0 ad=13.936p pd=54.12u as=13.936p ps=54.12u w=53.6u l=0.7u
X243 VSS a_41764_160995# a_41764_160995# VSS nfet_06v0 ad=13.936p pd=54.12u as=13.936p ps=54.12u w=53.6u l=0.7u
X244 a_41764_160995# a_41764_160995# VSS VSS nfet_06v0 ad=13.936p pd=54.12u as=13.936p ps=54.12u w=53.6u l=0.7u
X245 ESD_RAIL ESD_RAIL a_41764_148611# VSS nfet_06v0 ad=13.936p pd=54.12u as=13.936p ps=54.12u w=53.6u l=0.7u
X246 TERM_P_R DIFF_ENABLE TERM_N_R VSS nfet_03v3 ad=8.8p pd=40.88u as=8.8p ps=40.88u w=20u l=0.28u
X247 FS_P_BLEED_2 FS_P_BLEED_3 VSS ppolyf_u_1k r_width=1u r_length=12.5u
X248 TERM_OR_P_S TERM_ENABLE VDD VDD pfet_03v3 ad=1.76p pd=8.88u as=1.76p ps=8.88u w=4u l=0.28u
X249 TERM_GATE_N TERM_OR_N_B VDD VDD pfet_03v3 ad=3.52p pd=16.88u as=3.52p ps=16.88u w=8u l=0.28u
X250 VDD PULLUP_P_GATE PULLUP_P_WELL PULLUP_P_WELL pfet_03v3 ad=8.8p pd=40.88u as=8.8p ps=40.88u w=20u l=0.28u
X251 FS_P_OUT FS_P_GATE FS_P_WELL FS_P_WELL pfet_03v3 ad=6.16p pd=28.88u as=6.16p ps=28.88u w=14u l=0.28u
X252 VSS a_41764_160995# a_41764_160995# VSS nfet_06v0 ad=13.936p pd=54.12u as=13.936p ps=54.12u w=53.6u l=0.7u
X253 a_41764_148611# a_41764_148611# a_41764_160995# VSS nfet_06v0 ad=13.936p pd=54.12u as=13.936p ps=54.12u w=53.6u l=0.7u
X254 ESD_RAIL ESD_RAIL a_41764_148611# VSS nfet_06v0 ad=13.936p pd=54.12u as=13.936p ps=54.12u w=53.6u l=0.7u
X255 VDD FS_N_GATE FS_N_WELL FS_N_WELL pfet_03v3 ad=6.16p pd=28.88u as=6.16p ps=28.88u w=14u l=0.28u
X256 a_41764_160995# a_41764_160995# VSS VSS nfet_06v0 ad=13.936p pd=54.12u as=13.936p ps=54.12u w=53.6u l=0.7u
X257 TERM_N_R TERM_GATE_N TERM_VCM VSS nfet_03v3 ad=8.8p pd=40.88u as=8.8p ps=40.88u w=20u l=0.28u
X258 a_41764_160995# a_41764_160995# VSS VSS nfet_06v0 ad=13.936p pd=54.12u as=13.936p ps=54.12u w=53.6u l=0.7u
X259 HS_N_13 HS_N PAD_N VSS nfet_06v0 ad=8.8p pd=40.88u as=8.8p ps=40.88u w=20u l=0.7u
X260 a_41764_160995# a_41764_160995# VSS VSS nfet_06v0 ad=13.936p pd=54.12u as=23.584p ps=0.10808m w=53.6u l=0.7u
X261 FS_P_OUT FS_P_GATE FS_P_WELL FS_P_WELL pfet_03v3 ad=6.16p pd=28.88u as=6.16p ps=28.88u w=14u l=0.28u
X262 a_41764_160995# a_41764_160995# VSS VSS nfet_06v0 ad=13.936p pd=54.12u as=13.936p ps=54.12u w=53.6u l=0.7u
X263 a_41764_160995# a_41764_148611# a_41764_148611# VSS nfet_06v0 ad=23.584p pd=0.10808m as=13.936p ps=54.12u w=53.6u l=0.7u
X264 a_41764_160995# a_41764_148611# a_41764_148611# VSS nfet_06v0 ad=13.936p pd=54.12u as=13.936p ps=54.12u w=53.6u l=0.7u
X265 HS_N_2 HS_PBIAS VDD VDD pfet_03v3 ad=8.8p pd=40.88u as=8.8p ps=40.88u w=20u l=1u
X266 a_41764_160995# a_41764_148611# a_41764_148611# VSS nfet_06v0 ad=13.936p pd=54.12u as=13.936p ps=54.12u w=53.6u l=0.7u
X267 VSS a_42245_90628# ESD_RAIL VSS nfet_06v0 ad=13p pd=50.52u as=13p ps=50.52u w=50u l=0.7u
X268 VCM_LOW_OK TERM_VCM VDD VDD pfet_03v3 ad=0.88p pd=4.88u as=0.88p ps=4.88u w=2u l=0.28u
X269 a_41764_148611# ESD_RAIL ESD_RAIL VSS nfet_06v0 ad=13.936p pd=54.12u as=13.936p ps=54.12u w=53.6u l=0.7u
X270 a_41764_148611# ESD_RAIL ESD_RAIL VSS nfet_06v0 ad=13.936p pd=54.12u as=13.936p ps=54.12u w=53.6u l=0.7u
X271 a_41764_148611# a_41764_148611# a_41764_160995# VSS nfet_06v0 ad=13.936p pd=54.12u as=13.936p ps=54.12u w=53.6u l=0.7u
X272 PULLUP_N_BLEED_1 PULLUP_N_BLEED_2 VSS ppolyf_u_1k r_width=1u r_length=12.5u
X273 a_41764_148611# a_41764_148611# a_41764_160995# VSS nfet_06v0 ad=13.936p pd=54.12u as=13.936p ps=54.12u w=53.6u l=0.7u
X274 ESD_RAIL ESD_RAIL a_41764_148611# VSS nfet_06v0 ad=13.936p pd=54.12u as=13.936p ps=54.12u w=53.6u l=0.7u
X275 a_41764_160995# a_41764_160995# VSS VSS nfet_06v0 ad=13.936p pd=54.12u as=13.936p ps=54.12u w=53.6u l=0.7u
X276 ESD_RAIL a_42245_90628# VSS VSS nfet_06v0 ad=13p pd=50.52u as=13p ps=50.52u w=50u l=0.7u
X277 FS_N_BLEED_6 FS_N_GATE VSS ppolyf_u_1k r_width=1u r_length=12.5u
X278 a_41764_160995# a_41764_148611# a_41764_148611# VSS nfet_06v0 ad=13.936p pd=54.12u as=13.936p ps=54.12u w=53.6u l=0.7u
X279 VSS a_41764_160995# a_41764_160995# VSS nfet_06v0 ad=13.936p pd=54.12u as=13.936p ps=54.12u w=53.6u l=0.7u
X280 HS_P_11 HS_PBIAS VDD VDD pfet_03v3 ad=8.8p pd=40.88u as=8.8p ps=40.88u w=20u l=1u
X281 ESD_RAIL ESD_RAIL a_41764_148611# VSS nfet_06v0 ad=13.936p pd=54.12u as=13.936p ps=54.12u w=53.6u l=0.7u
X282 VSS a_41764_160995# a_41764_160995# VSS nfet_06v0 ad=13.936p pd=54.12u as=13.936p ps=54.12u w=53.6u l=0.7u
X283 a_41764_148611# a_41764_148611# a_41764_160995# VSS nfet_06v0 ad=13.936p pd=54.12u as=23.584p ps=0.10808m w=53.6u l=0.7u
X284 a_41764_148611# ESD_RAIL ESD_RAIL VSS nfet_06v0 ad=23.584p pd=0.10808m as=13.936p ps=54.12u w=53.6u l=0.7u
X285 a_41764_148611# a_41764_148611# a_41764_160995# VSS nfet_06v0 ad=13.936p pd=54.12u as=13.936p ps=54.12u w=53.6u l=0.7u
X286 a_41764_148611# ESD_RAIL ESD_RAIL VSS nfet_06v0 ad=13.936p pd=54.12u as=13.936p ps=54.12u w=53.6u l=0.7u
X287 a_41764_160995# a_41764_160995# VSS VSS nfet_06v0 ad=13.936p pd=54.12u as=13.936p ps=54.12u w=53.6u l=0.7u
X288 a_41764_148611# a_41764_148611# a_41764_160995# VSS nfet_06v0 ad=13.936p pd=54.12u as=13.936p ps=54.12u w=53.6u l=0.7u
X289 a_41764_148611# ESD_RAIL ESD_RAIL VSS nfet_06v0 ad=13.936p pd=54.12u as=13.936p ps=54.12u w=53.6u l=0.7u
X290 ESD_RAIL ESD_RAIL a_41764_148611# VSS nfet_06v0 ad=13.936p pd=54.12u as=13.936p ps=54.12u w=53.6u l=0.7u
X291 ESD_RAIL ESD_RAIL a_41764_148611# VSS nfet_06v0 ad=13.936p pd=54.12u as=23.584p ps=0.10808m w=53.6u l=0.7u
X292 a_41764_160995# a_41764_148611# a_41764_148611# VSS nfet_06v0 ad=13.936p pd=54.12u as=13.936p ps=54.12u w=53.6u l=0.7u
X293 VSS a_42245_90628# ESD_RAIL VSS nfet_06v0 ad=13p pd=50.52u as=13p ps=50.52u w=50u l=0.7u
X294 ESD_RAIL a_42245_90628# VSS VSS nfet_06v0 ad=13p pd=50.52u as=13p ps=50.52u w=50u l=0.7u
X295 FS_P_OUT FS_P_GATE FS_P_WELL FS_P_WELL pfet_03v3 ad=6.16p pd=28.88u as=6.16p ps=28.88u w=14u l=0.28u
X296 a_41764_160995# a_41764_148611# a_41764_148611# VSS nfet_06v0 ad=13.936p pd=54.12u as=13.936p ps=54.12u w=53.6u l=0.7u
X297 a_41764_160995# a_41764_148611# a_41764_148611# VSS nfet_06v0 ad=23.584p pd=0.10808m as=13.936p ps=54.12u w=53.6u l=0.7u
X298 FS_N_OUT FS_N_GATE FS_N_WELL FS_N_WELL pfet_03v3 ad=6.16p pd=28.88u as=6.16p ps=28.88u w=14u l=0.28u
X299 VSS a_41764_160995# a_41764_160995# VSS nfet_06v0 ad=13.936p pd=54.12u as=13.936p ps=54.12u w=53.6u l=0.7u
X300 VSS a_41764_160995# a_41764_160995# VSS nfet_06v0 ad=13.936p pd=54.12u as=13.936p ps=54.12u w=53.6u l=0.7u
X301 VSS a_41764_160995# a_41764_160995# VSS nfet_06v0 ad=13.936p pd=54.12u as=13.936p ps=54.12u w=53.6u l=0.7u
X302 a_41764_148611# a_41764_148611# a_41764_160995# VSS nfet_06v0 ad=13.936p pd=54.12u as=13.936p ps=54.12u w=53.6u l=0.7u
X303 PULLUP_P_OUT PAD_P VSS ppolyf_u_1k r_width=1u r_length=1.18u
X304 a_41764_148611# ESD_RAIL ESD_RAIL VSS nfet_06v0 ad=13.936p pd=54.12u as=13.936p ps=54.12u w=53.6u l=0.7u
X305 FS_P_OUT FS_P_GATE FS_P_WELL FS_P_WELL pfet_03v3 ad=6.16p pd=28.88u as=6.16p ps=28.88u w=14u l=0.28u
X306 a_41764_148611# ESD_RAIL ESD_RAIL VSS nfet_06v0 ad=23.584p pd=0.10808m as=13.936p ps=54.12u w=53.6u l=0.7u
X307 FS_N_OUT FS_N_GATE FS_N_WELL FS_N_WELL pfet_03v3 ad=6.16p pd=28.88u as=6.16p ps=28.88u w=14u l=0.28u
X308 a_41764_160995# a_41764_160995# VSS VSS nfet_06v0 ad=13.936p pd=54.12u as=13.936p ps=54.12u w=53.6u l=0.7u
X309 FS_P_OUT FS_P_GATE FS_P_WELL FS_P_WELL pfet_03v3 ad=6.16p pd=28.88u as=6.16p ps=28.88u w=14u l=0.28u
X310 HS_P_3 HS_PBIAS VDD VDD pfet_03v3 ad=8.8p pd=40.88u as=8.8p ps=40.88u w=20u l=1u
X311 FS_N_BLEED_0 FS_N_BLEED_1 VSS ppolyf_u_1k r_width=1u r_length=12.5u
X312 TERM_OR_N_NS VCM_LOW_OK VSS VSS nfet_03v3 ad=1.76p pd=8.88u as=1.76p ps=8.88u w=4u l=0.28u
X313 VSS a_41764_160995# a_41764_160995# VSS nfet_06v0 ad=13.936p pd=54.12u as=13.936p ps=54.12u w=53.6u l=0.7u
D6 VSS PULLUP_P diode_nd2ps_03v3 pj=6.2u area=2.4025p
X314 ESD_RAIL a_42245_90628# VSS VSS nfet_06v0 ad=13p pd=50.52u as=13p ps=50.52u w=50u l=0.7u
X315 VSS a_41764_160995# a_41764_160995# VSS nfet_06v0 ad=13.936p pd=54.12u as=13.936p ps=54.12u w=53.6u l=0.7u
X316 a_41764_148611# a_41764_148611# a_41764_160995# VSS nfet_06v0 ad=13.936p pd=54.12u as=13.936p ps=54.12u w=53.6u l=0.7u
X317 a_41764_148611# ESD_RAIL ESD_RAIL VSS nfet_06v0 ad=13.936p pd=54.12u as=13.936p ps=54.12u w=53.6u l=0.7u
X318 a_41764_160995# a_41764_160995# VSS VSS nfet_06v0 ad=13.936p pd=54.12u as=23.584p ps=0.10808m w=53.6u l=0.7u
X319 a_41764_148611# a_41764_148611# a_41764_160995# VSS nfet_06v0 ad=13.936p pd=54.12u as=13.936p ps=54.12u w=53.6u l=0.7u
X320 a_41764_148611# ESD_RAIL ESD_RAIL VSS nfet_06v0 ad=13.936p pd=54.12u as=13.936p ps=54.12u w=53.6u l=0.7u
X321 a_41764_160995# a_41764_160995# VSS VSS nfet_06v0 ad=13.936p pd=54.12u as=23.584p ps=0.10808m w=53.6u l=0.7u
X322 a_41764_160995# a_41764_160995# VSS VSS nfet_06v0 ad=13.936p pd=54.12u as=13.936p ps=54.12u w=53.6u l=0.7u
X323 FS_P_OUT FS_P_GATE FS_P_WELL FS_P_WELL pfet_03v3 ad=6.16p pd=28.88u as=6.16p ps=28.88u w=14u l=0.28u
X324 VSS a_42245_90628# ESD_RAIL VSS nfet_06v0 ad=13p pd=50.52u as=13p ps=50.52u w=50u l=0.7u
X325 a_41764_160995# a_41764_148611# a_41764_148611# VSS nfet_06v0 ad=13.936p pd=54.12u as=13.936p ps=54.12u w=53.6u l=0.7u
X326 ESD_RAIL ESD_RAIL a_41764_148611# VSS nfet_06v0 ad=13.936p pd=54.12u as=13.936p ps=54.12u w=53.6u l=0.7u
X327 ESD_RAIL ESD_RAIL a_41764_148611# VSS nfet_06v0 ad=13.936p pd=54.12u as=13.936p ps=54.12u w=53.6u l=0.7u
X328 a_41764_160995# a_41764_148611# a_41764_148611# VSS nfet_06v0 ad=13.936p pd=54.12u as=13.936p ps=54.12u w=53.6u l=0.7u
X329 FS_P_OUT FS_P_GATE FS_P_WELL FS_P_WELL pfet_03v3 ad=6.16p pd=28.88u as=6.16p ps=28.88u w=14u l=0.28u
X330 a_41764_160995# a_41764_148611# a_41764_148611# VSS nfet_06v0 ad=13.936p pd=54.12u as=13.936p ps=54.12u w=53.6u l=0.7u
X331 a_41764_148611# a_41764_148611# a_41764_160995# VSS nfet_06v0 ad=13.936p pd=54.12u as=13.936p ps=54.12u w=53.6u l=0.7u
X332 FS_N_OUT FS_N_GATE FS_N_WELL FS_N_WELL pfet_03v3 ad=6.16p pd=28.88u as=6.16p ps=28.88u w=14u l=0.28u
X333 VSS a_41764_160995# a_41764_160995# VSS nfet_06v0 ad=13.936p pd=54.12u as=13.936p ps=54.12u w=53.6u l=0.7u
X334 VSS a_41764_160995# a_41764_160995# VSS nfet_06v0 ad=23.584p pd=0.10808m as=13.936p ps=54.12u w=53.6u l=0.7u
X335 VDD PULLUP_N_GATE PULLUP_N_WELL PULLUP_N_WELL pfet_03v3 ad=8.8p pd=40.88u as=8.8p ps=40.88u w=20u l=0.28u
X336 ESD_RAIL a_42245_90628# VSS VSS nfet_06v0 ad=13p pd=50.52u as=13p ps=50.52u w=50u l=0.7u
X337 a_41764_160995# a_41764_160995# VSS VSS nfet_06v0 ad=13.936p pd=54.12u as=13.936p ps=54.12u w=53.6u l=0.7u
X338 a_41764_148611# a_41764_148611# a_41764_160995# VSS nfet_06v0 ad=13.936p pd=54.12u as=13.936p ps=54.12u w=53.6u l=0.7u
D7 VSS ESD_RAIL diode_nd2ps_06v0 pj=82u area=40p
X339 ESD_RAIL ESD_RAIL a_41764_148611# VSS nfet_06v0 ad=13.936p pd=54.12u as=13.936p ps=54.12u w=53.6u l=0.7u
X340 FS_N_OUT FS_N_GATE FS_N_WELL FS_N_WELL pfet_03v3 ad=6.16p pd=28.88u as=6.16p ps=28.88u w=14u l=0.28u
X341 a_44789_117064# a_43813_117064# VSS VSS nfet_06v0 ad=1.3p pd=5.52u as=2.2p ps=10.88u w=5u l=0.7u
X342 ESD_RAIL ESD_RAIL a_41764_148611# VSS nfet_06v0 ad=13.936p pd=54.12u as=13.936p ps=54.12u w=53.6u l=0.7u
X343 VSS a_42245_90628# ESD_RAIL VSS nfet_06v0 ad=13p pd=50.52u as=13p ps=50.52u w=50u l=0.7u
X344 HS_P_13 HS_PBIAS VDD VDD pfet_03v3 ad=8.8p pd=40.88u as=8.8p ps=40.88u w=20u l=1u
D8 VSS ESD_RAIL diode_nd2ps_06v0 pj=82u area=40p
X345 ESD_RAIL ESD_RAIL a_41764_148611# VSS nfet_06v0 ad=13.936p pd=54.12u as=13.936p ps=54.12u w=53.6u l=0.7u
X346 VSS a_41764_160995# a_41764_160995# VSS nfet_06v0 ad=13.936p pd=54.12u as=13.936p ps=54.12u w=53.6u l=0.7u
X347 a_41764_160995# a_41764_160995# VSS VSS nfet_06v0 ad=13.936p pd=54.12u as=13.936p ps=54.12u w=53.6u l=0.7u
X348 a_41764_160995# a_41764_148611# a_41764_148611# VSS nfet_06v0 ad=13.936p pd=54.12u as=13.936p ps=54.12u w=53.6u l=0.7u
X349 a_41764_148611# ESD_RAIL ESD_RAIL VSS nfet_06v0 ad=13.936p pd=54.12u as=13.936p ps=54.12u w=53.6u l=0.7u
X350 TERM_P_R DIFF_ENABLE TERM_N_R VSS nfet_03v3 ad=8.8p pd=40.88u as=8.8p ps=40.88u w=20u l=0.28u
X351 PAD_N DIV_N VSS ppolyf_u_1k r_width=1u r_length=2u
X352 a_41764_148611# a_41764_148611# a_41764_160995# VSS nfet_06v0 ad=13.936p pd=54.12u as=13.936p ps=54.12u w=53.6u l=0.7u
X353 TERM_GATE_N_BLEED_1 TERM_GATE_N_BLEED_2 VSS ppolyf_u_1k r_width=1u r_length=12.5u
X354 a_41764_160995# a_41764_148611# a_41764_148611# VSS nfet_06v0 ad=13.936p pd=54.12u as=13.936p ps=54.12u w=53.6u l=0.7u
X355 a_41764_148611# ESD_RAIL ESD_RAIL VSS nfet_06v0 ad=13.936p pd=54.12u as=13.936p ps=54.12u w=53.6u l=0.7u
X356 ESD_RAIL ESD_RAIL a_41764_148611# VSS nfet_06v0 ad=13.936p pd=54.12u as=13.936p ps=54.12u w=53.6u l=0.7u
X357 a_41764_160995# a_41764_160995# VSS VSS nfet_06v0 ad=13.936p pd=54.12u as=13.936p ps=54.12u w=53.6u l=0.7u
X358 PULLUP_P_BLEED_4 PULLUP_P_BLEED_5 VSS ppolyf_u_1k r_width=1u r_length=12.5u
X359 a_41764_160995# a_41764_148611# a_41764_148611# VSS nfet_06v0 ad=13.936p pd=54.12u as=13.936p ps=54.12u w=53.6u l=0.7u
X360 FS_N_OUT FS_N_GATE FS_N_WELL FS_N_WELL pfet_03v3 ad=6.16p pd=28.88u as=6.16p ps=28.88u w=14u l=0.28u
X361 ESD_RAIL a_42245_90628# VSS VSS nfet_06v0 ad=13p pd=50.52u as=13p ps=50.52u w=50u l=0.7u
X362 a_41764_148611# ESD_RAIL ESD_RAIL VSS nfet_06v0 ad=13.936p pd=54.12u as=13.936p ps=54.12u w=53.6u l=0.7u
X363 FS_N_OUT FS_N_GATE FS_N_WELL FS_N_WELL pfet_03v3 ad=6.16p pd=28.88u as=6.16p ps=28.88u w=14u l=0.28u
X364 VSS a_41764_160995# a_41764_160995# VSS nfet_06v0 ad=23.584p pd=0.10808m as=13.936p ps=54.12u w=53.6u l=0.7u
X365 FS_P_OUT FS_P_GATE FS_P_WELL FS_P_WELL pfet_03v3 ad=6.16p pd=28.88u as=6.16p ps=28.88u w=14u l=0.28u
X366 a_41764_148611# a_41764_148611# a_41764_160995# VSS nfet_06v0 ad=13.936p pd=54.12u as=13.936p ps=54.12u w=53.6u l=0.7u
X367 a_41764_148611# a_41764_148611# a_41764_160995# VSS nfet_06v0 ad=13.936p pd=54.12u as=13.936p ps=54.12u w=53.6u l=0.7u
X368 a_41764_148611# ESD_RAIL ESD_RAIL VSS nfet_06v0 ad=23.584p pd=0.10808m as=13.936p ps=54.12u w=53.6u l=0.7u
X369 a_41764_148611# ESD_RAIL ESD_RAIL VSS nfet_06v0 ad=13.936p pd=54.12u as=13.936p ps=54.12u w=53.6u l=0.7u
X370 FS_N_CONTROL_S VDD VSS VSS nfet_03v3 ad=1.76p pd=8.88u as=1.76p ps=8.88u w=4u l=0.28u
X371 FS_N_OUT FS_N_GATE FS_N_WELL FS_N_WELL pfet_03v3 ad=6.16p pd=28.88u as=6.16p ps=28.88u w=14u l=0.28u
X372 a_41764_148611# a_41764_148611# a_41764_160995# VSS nfet_06v0 ad=13.936p pd=54.12u as=23.584p ps=0.10808m w=53.6u l=0.7u
X373 a_41764_148611# a_41764_148611# a_41764_160995# VSS nfet_06v0 ad=13.936p pd=54.12u as=13.936p ps=54.12u w=53.6u l=0.7u
X374 a_41005_131825# a_53878_131545# ESD_RAIL ppolyf_u r_width=0.8u r_length=63.855u
X375 PULLUP_N_BLEED_5 PULLUP_N_BLEED_6 VSS ppolyf_u_1k r_width=1u r_length=12.5u
X376 ESD_RAIL ESD_RAIL a_41764_148611# VSS nfet_06v0 ad=13.936p pd=54.12u as=23.584p ps=0.10808m w=53.6u l=0.7u
X377 a_41764_148611# ESD_RAIL ESD_RAIL VSS nfet_06v0 ad=13.936p pd=54.12u as=13.936p ps=54.12u w=53.6u l=0.7u
X378 VSS a_41764_160995# a_41764_160995# VSS nfet_06v0 ad=13.936p pd=54.12u as=13.936p ps=54.12u w=53.6u l=0.7u
X379 a_41764_148611# a_41764_148611# a_41764_160995# VSS nfet_06v0 ad=13.936p pd=54.12u as=13.936p ps=54.12u w=53.6u l=0.7u
X380 PULLUP_P_GATE PULLUP_P PULLUP_P_CONTROL_S VSS nfet_06v0 ad=0.88p pd=4.88u as=0.88p ps=4.88u w=2u l=0.7u
X381 a_41764_160995# a_41764_160995# VSS VSS nfet_06v0 ad=13.936p pd=54.12u as=13.936p ps=54.12u w=53.6u l=0.7u
X382 VCM_LOW_OK TERM_VCM VSS VSS nfet_03v3 ad=3.52p pd=16.88u as=3.52p ps=16.88u w=8u l=0.28u
X383 TERM_OR_P_B VCM_LOW_OK TERM_OR_P_S VDD pfet_03v3 ad=1.76p pd=8.88u as=1.76p ps=8.88u w=4u l=0.28u
X384 ESD_RAIL ESD_RAIL a_41764_148611# VSS nfet_06v0 ad=13.936p pd=54.12u as=13.936p ps=54.12u w=53.6u l=0.7u
X385 a_41764_160995# a_41764_160995# VSS VSS nfet_06v0 ad=13.936p pd=54.12u as=13.936p ps=54.12u w=53.6u l=0.7u
X386 a_41764_160995# a_41764_148611# a_41764_148611# VSS nfet_06v0 ad=13.936p pd=54.12u as=13.936p ps=54.12u w=53.6u l=0.7u
X387 a_41764_160995# a_41764_148611# a_41764_148611# VSS nfet_06v0 ad=13.936p pd=54.12u as=13.936p ps=54.12u w=53.6u l=0.7u
X388 ESD_RAIL ESD_RAIL a_41764_148611# VSS nfet_06v0 ad=13.936p pd=54.12u as=13.936p ps=54.12u w=53.6u l=0.7u
X389 VSS a_41764_160995# a_41764_160995# VSS nfet_06v0 ad=13.936p pd=54.12u as=13.936p ps=54.12u w=53.6u l=0.7u
X390 a_41764_148611# ESD_RAIL ESD_RAIL VSS nfet_06v0 ad=13.936p pd=54.12u as=13.936p ps=54.12u w=53.6u l=0.7u
X391 TERM_GATE_P_BLEED_2 VSS VSS ppolyf_u_1k r_width=1u r_length=12.5u
X392 FS_N_OUT FS_N_GATE FS_N_WELL FS_N_WELL pfet_03v3 ad=6.16p pd=28.88u as=6.16p ps=28.88u w=14u l=0.28u
X393 a_41764_148611# a_41764_148611# a_41764_160995# VSS nfet_06v0 ad=13.936p pd=54.12u as=13.936p ps=54.12u w=53.6u l=0.7u
X394 a_41764_160995# a_41764_160995# VSS VSS nfet_06v0 ad=13.936p pd=54.12u as=13.936p ps=54.12u w=53.6u l=0.7u
X395 ESD_RAIL ESD_RAIL a_41764_148611# VSS nfet_06v0 ad=13.936p pd=54.12u as=13.936p ps=54.12u w=53.6u l=0.7u
X396 a_41764_160995# a_41764_160995# VSS VSS nfet_06v0 ad=13.936p pd=54.12u as=13.936p ps=54.12u w=53.6u l=0.7u
X397 HS_N_11 HS_PBIAS VDD VDD pfet_03v3 ad=8.8p pd=40.88u as=8.8p ps=40.88u w=20u l=1u
D9 VSS FS_LOW_N diode_nd2ps_03v3 pj=2.4u area=0.36p
X398 a_41764_160995# a_41764_160995# VSS VSS nfet_06v0 ad=13.936p pd=54.12u as=13.936p ps=54.12u w=53.6u l=0.7u
X399 a_41764_160995# a_41764_160995# VSS VSS nfet_06v0 ad=13.936p pd=54.12u as=13.936p ps=54.12u w=53.6u l=0.7u
X400 a_41764_160995# a_41764_148611# a_41764_148611# VSS nfet_06v0 ad=13.936p pd=54.12u as=13.936p ps=54.12u w=53.6u l=0.7u
X401 a_41764_160995# a_41764_148611# a_41764_148611# VSS nfet_06v0 ad=13.936p pd=54.12u as=13.936p ps=54.12u w=53.6u l=0.7u
X402 a_41764_160995# a_41764_148611# a_41764_148611# VSS nfet_06v0 ad=13.936p pd=54.12u as=13.936p ps=54.12u w=53.6u l=0.7u
X403 VSS a_42245_90628# ESD_RAIL VSS nfet_06v0 ad=13p pd=50.52u as=13p ps=50.52u w=50u l=0.7u
X404 a_41764_148611# ESD_RAIL ESD_RAIL VSS nfet_06v0 ad=13.936p pd=54.12u as=13.936p ps=54.12u w=53.6u l=0.7u
X405 VSS a_41764_160995# a_41764_160995# VSS nfet_06v0 ad=13.936p pd=54.12u as=13.936p ps=54.12u w=53.6u l=0.7u
X406 ESD_RAIL a_44789_117064# a_42245_90628# ESD_RAIL pfet_06v0 ad=1.3p pd=5.52u as=1.3p ps=5.52u w=5u l=0.7u
X407 a_41764_148611# ESD_RAIL ESD_RAIL VSS nfet_06v0 ad=13.936p pd=54.12u as=13.936p ps=54.12u w=53.6u l=0.7u
X408 a_41764_148611# a_41764_148611# a_41764_160995# VSS nfet_06v0 ad=13.936p pd=54.12u as=13.936p ps=54.12u w=53.6u l=0.7u
X409 a_41764_148611# ESD_RAIL ESD_RAIL VSS nfet_06v0 ad=13.936p pd=54.12u as=13.936p ps=54.12u w=53.6u l=0.7u
X410 a_41005_132945# a_53878_132665# ESD_RAIL ppolyf_u r_width=0.8u r_length=63.855u
X411 a_41764_160995# a_41764_160995# VSS VSS nfet_06v0 ad=13.936p pd=54.12u as=13.936p ps=54.12u w=53.6u l=0.7u
D10 VSS PAD_P diode_nd2ps_06v0 pj=51.8u area=22.5p
X412 HS_P_10 HS_P PAD_P VSS nfet_06v0 ad=8.8p pd=40.88u as=8.8p ps=40.88u w=20u l=0.7u
X413 FS_N_OUT FS_N_GATE FS_N_WELL FS_N_WELL pfet_03v3 ad=6.16p pd=28.88u as=6.16p ps=28.88u w=14u l=0.28u
X414 a_41764_160995# a_41764_148611# a_41764_148611# VSS nfet_06v0 ad=13.936p pd=54.12u as=13.936p ps=54.12u w=53.6u l=0.7u
X415 ESD_RAIL ESD_RAIL a_41764_148611# VSS nfet_06v0 ad=13.936p pd=54.12u as=13.936p ps=54.12u w=53.6u l=0.7u
X416 PAD_N PULLDOWN_N_R VSS ppolyf_u_1k r_width=1u r_length=14.2u
X417 TERM_P_R TERM_GATE_P TERM_VCM VSS nfet_03v3 ad=8.8p pd=40.88u as=8.8p ps=40.88u w=20u l=0.28u
X418 VSS a_41764_160995# a_41764_160995# VSS nfet_06v0 ad=13.936p pd=54.12u as=13.936p ps=54.12u w=53.6u l=0.7u
X419 ESD_RAIL a_42245_90628# VSS VSS nfet_06v0 ad=13p pd=50.52u as=13p ps=50.52u w=50u l=0.7u
X420 PAD_P BYPASS_ENABLE RX_P VSS nfet_06v0 ad=8.8p pd=40.88u as=8.8p ps=40.88u w=20u l=0.7u
X421 VSS a_41764_160995# a_41764_160995# VSS nfet_06v0 ad=23.584p pd=0.10808m as=13.936p ps=54.12u w=53.6u l=0.7u
X422 FS_N_OUT FS_N_GATE FS_N_WELL FS_N_WELL pfet_03v3 ad=6.16p pd=28.88u as=6.16p ps=28.88u w=14u l=0.28u
X423 a_41764_160995# a_41764_148611# a_41764_148611# VSS nfet_06v0 ad=13.936p pd=54.12u as=13.936p ps=54.12u w=53.6u l=0.7u
X424 HS_P_5 HS_P PAD_P VSS nfet_06v0 ad=8.8p pd=40.88u as=8.8p ps=40.88u w=20u l=0.7u
X425 ESD_RAIL ESD_RAIL a_41764_148611# VSS nfet_06v0 ad=13.936p pd=54.12u as=13.936p ps=54.12u w=53.6u l=0.7u
X426 VSS a_41764_160995# a_41764_160995# VSS nfet_06v0 ad=13.936p pd=54.12u as=13.936p ps=54.12u w=53.6u l=0.7u
X427 VSS a_41764_160995# a_41764_160995# VSS nfet_06v0 ad=13.936p pd=54.12u as=13.936p ps=54.12u w=53.6u l=0.7u
X428 a_41764_148611# a_41764_148611# a_41764_160995# VSS nfet_06v0 ad=13.936p pd=54.12u as=23.584p ps=0.10808m w=53.6u l=0.7u
X429 VSS a_41764_160995# a_41764_160995# VSS nfet_06v0 ad=13.936p pd=54.12u as=13.936p ps=54.12u w=53.6u l=0.7u
X430 a_41764_148611# a_41764_148611# a_41764_160995# VSS nfet_06v0 ad=13.936p pd=54.12u as=23.584p ps=0.10808m w=53.6u l=0.7u
X431 a_41764_148611# a_41764_148611# a_41764_160995# VSS nfet_06v0 ad=13.936p pd=54.12u as=13.936p ps=54.12u w=53.6u l=0.7u
X432 VSS a_42245_90628# ESD_RAIL VSS nfet_06v0 ad=13p pd=50.52u as=13p ps=50.52u w=50u l=0.7u
X433 a_41764_148611# ESD_RAIL ESD_RAIL VSS nfet_06v0 ad=13.936p pd=54.12u as=13.936p ps=54.12u w=53.6u l=0.7u
X434 DIV_P DIV_ENABLE RX_P VSS nfet_06v0 ad=8.8p pd=40.88u as=8.8p ps=40.88u w=20u l=0.7u
X435 a_41764_148611# ESD_RAIL ESD_RAIL VSS nfet_06v0 ad=13.936p pd=54.12u as=13.936p ps=54.12u w=53.6u l=0.7u
X436 VSS a_42245_90628# ESD_RAIL VSS nfet_06v0 ad=13p pd=50.52u as=13p ps=50.52u w=50u l=0.7u
X437 ESD_RAIL ESD_RAIL a_41764_148611# VSS nfet_06v0 ad=13.936p pd=54.12u as=23.584p ps=0.10808m w=53.6u l=0.7u
X438 ESD_RAIL ESD_RAIL a_41764_148611# VSS nfet_06v0 ad=13.936p pd=54.12u as=23.584p ps=0.10808m w=53.6u l=0.7u
X439 ESD_RAIL ESD_RAIL a_41764_148611# VSS nfet_06v0 ad=13.936p pd=54.12u as=13.936p ps=54.12u w=53.6u l=0.7u
X440 VSS a_41764_160995# a_41764_160995# VSS nfet_06v0 ad=13.936p pd=54.12u as=13.936p ps=54.12u w=53.6u l=0.7u
X441 HS_P_6 HS_P PAD_P VSS nfet_06v0 ad=8.8p pd=40.88u as=8.8p ps=40.88u w=20u l=0.7u
X442 FS_N_OUT FS_N_GATE FS_N_WELL FS_N_WELL pfet_03v3 ad=6.16p pd=28.88u as=6.16p ps=28.88u w=14u l=0.28u
X443 a_41764_160995# a_41764_160995# VSS VSS nfet_06v0 ad=13.936p pd=54.12u as=13.936p ps=54.12u w=53.6u l=0.7u
X444 a_41764_160995# a_41764_148611# a_41764_148611# VSS nfet_06v0 ad=13.936p pd=54.12u as=13.936p ps=54.12u w=53.6u l=0.7u
X445 a_41764_160995# a_41764_148611# a_41764_148611# VSS nfet_06v0 ad=23.584p pd=0.10808m as=13.936p ps=54.12u w=53.6u l=0.7u
X446 ESD_RAIL a_42245_90628# VSS VSS nfet_06v0 ad=13p pd=50.52u as=13p ps=50.52u w=50u l=0.7u
X447 VSS a_41764_160995# a_41764_160995# VSS nfet_06v0 ad=13.936p pd=54.12u as=13.936p ps=54.12u w=53.6u l=0.7u
X448 a_41764_148611# a_41764_148611# a_41764_160995# VSS nfet_06v0 ad=13.936p pd=54.12u as=13.936p ps=54.12u w=53.6u l=0.7u
X449 a_41764_148611# ESD_RAIL ESD_RAIL VSS nfet_06v0 ad=13.936p pd=54.12u as=13.936p ps=54.12u w=53.6u l=0.7u
X450 a_41764_148611# ESD_RAIL ESD_RAIL VSS nfet_06v0 ad=13.936p pd=54.12u as=13.936p ps=54.12u w=53.6u l=0.7u
X451 a_41764_160995# a_41764_160995# VSS VSS nfet_06v0 ad=13.936p pd=54.12u as=13.936p ps=54.12u w=53.6u l=0.7u
X452 a_41764_148611# ESD_RAIL ESD_RAIL VSS nfet_06v0 ad=13.936p pd=54.12u as=13.936p ps=54.12u w=53.6u l=0.7u
X453 a_42245_90628# a_44789_117064# ESD_RAIL ESD_RAIL pfet_06v0 ad=1.3p pd=5.52u as=1.3p ps=5.52u w=5u l=0.7u
X454 a_43813_117064# a_41005_131545# ESD_RAIL ESD_RAIL pfet_06v0 ad=1.3p pd=5.52u as=1.3p ps=5.52u w=5u l=0.7u
X455 a_41764_148611# ESD_RAIL ESD_RAIL VSS nfet_06v0 ad=13.936p pd=54.12u as=13.936p ps=54.12u w=53.6u l=0.7u
X456 FS_N_OUT FS_N_GATE FS_N_WELL FS_N_WELL pfet_03v3 ad=6.16p pd=28.88u as=6.16p ps=28.88u w=14u l=0.28u
X457 a_41764_160995# a_41764_160995# VSS VSS nfet_06v0 ad=13.936p pd=54.12u as=13.936p ps=54.12u w=53.6u l=0.7u
X458 a_41764_160995# a_41764_148611# a_41764_148611# VSS nfet_06v0 ad=13.936p pd=54.12u as=13.936p ps=54.12u w=53.6u l=0.7u
X459 a_41764_148611# a_41764_148611# a_41764_160995# VSS nfet_06v0 ad=13.936p pd=54.12u as=13.936p ps=54.12u w=53.6u l=0.7u
X460 ESD_RAIL ESD_RAIL a_41764_148611# VSS nfet_06v0 ad=13.936p pd=54.12u as=13.936p ps=54.12u w=53.6u l=0.7u
X461 ESD_RAIL ESD_RAIL a_41764_148611# VSS nfet_06v0 ad=13.936p pd=54.12u as=13.936p ps=54.12u w=53.6u l=0.7u
X462 a_41764_148611# ESD_RAIL ESD_RAIL VSS nfet_06v0 ad=13.936p pd=54.12u as=13.936p ps=54.12u w=53.6u l=0.7u
X463 VDD PULLUP_N_GATE PULLUP_N_WELL PULLUP_N_WELL pfet_03v3 ad=8.8p pd=40.88u as=8.8p ps=40.88u w=20u l=0.28u
X464 a_41764_148611# a_41764_148611# a_41764_160995# VSS nfet_06v0 ad=13.936p pd=54.12u as=13.936p ps=54.12u w=53.6u l=0.7u
X465 a_41764_160995# a_41764_160995# VSS VSS nfet_06v0 ad=13.936p pd=54.12u as=13.936p ps=54.12u w=53.6u l=0.7u
X466 VSS a_41764_160995# a_41764_160995# VSS nfet_06v0 ad=13.936p pd=54.12u as=13.936p ps=54.12u w=53.6u l=0.7u
X467 TERM_P_R TERM_GATE_P TERM_VCM VSS nfet_03v3 ad=8.8p pd=40.88u as=8.8p ps=40.88u w=20u l=0.28u
X468 a_41764_160995# a_41764_160995# VSS VSS nfet_06v0 ad=13.936p pd=54.12u as=13.936p ps=54.12u w=53.6u l=0.7u
X469 ESD_RAIL ESD_RAIL a_41764_148611# VSS nfet_06v0 ad=13.936p pd=54.12u as=23.584p ps=0.10808m w=53.6u l=0.7u
X470 ESD_RAIL ESD_RAIL a_41764_148611# VSS nfet_06v0 ad=13.936p pd=54.12u as=23.584p ps=0.10808m w=53.6u l=0.7u
X471 a_44789_117064# a_43813_117064# ESD_RAIL ESD_RAIL pfet_06v0 ad=2.2p pd=10.88u as=1.3p ps=5.52u w=5u l=0.7u
X472 ESD_RAIL ESD_RAIL a_41764_148611# VSS nfet_06v0 ad=13.936p pd=54.12u as=13.936p ps=54.12u w=53.6u l=0.7u
X473 HS_P_3 HS_P PAD_P VSS nfet_06v0 ad=8.8p pd=40.88u as=8.8p ps=40.88u w=20u l=0.7u
X474 FS_P_WELL FS_P_BLEED_0 VSS ppolyf_u_1k r_width=1u r_length=12.5u
X475 a_41764_160995# a_41764_148611# a_41764_148611# VSS nfet_06v0 ad=23.584p pd=0.10808m as=13.936p ps=54.12u w=53.6u l=0.7u
X476 VDD FS_P_GATE FS_P_WELL FS_P_WELL pfet_03v3 ad=6.16p pd=28.88u as=6.16p ps=28.88u w=14u l=0.28u
X477 VSS a_41764_160995# a_41764_160995# VSS nfet_06v0 ad=13.936p pd=54.12u as=13.936p ps=54.12u w=53.6u l=0.7u
D11 VSS PAD_N diode_nd2ps_06v0 pj=51.8u area=22.5p
X478 ESD_RAIL a_42245_90628# VSS VSS nfet_06v0 ad=13p pd=50.52u as=13p ps=50.52u w=50u l=0.7u
X479 a_41764_148611# ESD_RAIL ESD_RAIL VSS nfet_06v0 ad=23.584p pd=0.10808m as=13.936p ps=54.12u w=53.6u l=0.7u
X480 FS_P_BLEED_1 FS_P_BLEED_2 VSS ppolyf_u_1k r_width=1u r_length=12.5u
X481 VDD FS_P_GATE FS_P_WELL FS_P_WELL pfet_03v3 ad=6.16p pd=28.88u as=6.16p ps=28.88u w=14u l=0.28u
X482 a_41764_160995# a_41764_160995# VSS VSS nfet_06v0 ad=13.936p pd=54.12u as=13.936p ps=54.12u w=53.6u l=0.7u
X483 ESD_RAIL ESD_RAIL a_41764_148611# VSS nfet_06v0 ad=13.936p pd=54.12u as=13.936p ps=54.12u w=53.6u l=0.7u
X484 PULLUP_P_OUT PULLUP_P_GATE PULLUP_P_WELL PULLUP_P_WELL pfet_03v3 ad=8.8p pd=40.88u as=8.8p ps=40.88u w=20u l=0.28u
X485 VSS a_41764_160995# a_41764_160995# VSS nfet_06v0 ad=13.936p pd=54.12u as=13.936p ps=54.12u w=53.6u l=0.7u
X486 a_41764_160995# a_41764_148611# a_41764_148611# VSS nfet_06v0 ad=13.936p pd=54.12u as=13.936p ps=54.12u w=53.6u l=0.7u
X487 VSS a_42245_90628# ESD_RAIL VSS nfet_06v0 ad=13p pd=50.52u as=13p ps=50.52u w=50u l=0.7u
X488 VSS ESD_RAIL VSS ppolyf_u_1k_6p0 r_width=1u r_length=9.98874m
X489 a_41764_148611# ESD_RAIL ESD_RAIL VSS nfet_06v0 ad=13.936p pd=54.12u as=13.936p ps=54.12u w=53.6u l=0.7u
X490 TERM_N_R TERM_GATE_N TERM_VCM VSS nfet_03v3 ad=8.8p pd=40.88u as=8.8p ps=40.88u w=20u l=0.28u
X491 VSS a_41764_160995# a_41764_160995# VSS nfet_06v0 ad=13.936p pd=54.12u as=13.936p ps=54.12u w=53.6u l=0.7u
X492 a_41764_148611# a_41764_148611# a_41764_160995# VSS nfet_06v0 ad=13.936p pd=54.12u as=13.936p ps=54.12u w=53.6u l=0.7u
X493 a_41764_148611# a_41764_148611# a_41764_160995# VSS nfet_06v0 ad=13.936p pd=54.12u as=13.936p ps=54.12u w=53.6u l=0.7u
X494 ESD_RAIL ESD_RAIL a_41764_148611# VSS nfet_06v0 ad=13.936p pd=54.12u as=23.584p ps=0.10808m w=53.6u l=0.7u
X495 HS_P_12 HS_P PAD_P VSS nfet_06v0 ad=8.8p pd=40.88u as=8.8p ps=40.88u w=20u l=0.7u
X496 a_41764_148611# ESD_RAIL ESD_RAIL VSS nfet_06v0 ad=13.936p pd=54.12u as=13.936p ps=54.12u w=53.6u l=0.7u
X497 FS_N_OUT FS_N_GATE FS_N_WELL FS_N_WELL pfet_03v3 ad=6.16p pd=28.88u as=6.16p ps=28.88u w=14u l=0.28u
X498 a_41764_160995# a_41764_160995# VSS VSS nfet_06v0 ad=13.936p pd=54.12u as=13.936p ps=54.12u w=53.6u l=0.7u
X499 ESD_RAIL a_44789_117064# a_42245_90628# ESD_RAIL pfet_06v0 ad=2.2p pd=10.88u as=1.3p ps=5.52u w=5u l=0.7u
X500 a_42245_90628# a_44789_117064# ESD_RAIL ESD_RAIL pfet_06v0 ad=1.3p pd=5.52u as=1.3p ps=5.52u w=5u l=0.7u
X501 a_41764_160995# a_41764_148611# a_41764_148611# VSS nfet_06v0 ad=13.936p pd=54.12u as=13.936p ps=54.12u w=53.6u l=0.7u
X502 VSS a_42245_90628# ESD_RAIL VSS nfet_06v0 ad=13p pd=50.52u as=13p ps=50.52u w=50u l=0.7u
X503 PAD_N TERM_N_R VSS ppolyf_u r_width=16u r_length=1.3u
X504 HS_N_1 HS_PBIAS VDD VDD pfet_03v3 ad=8.8p pd=40.88u as=8.8p ps=40.88u w=20u l=1u
X505 a_41764_148611# ESD_RAIL ESD_RAIL VSS nfet_06v0 ad=13.936p pd=54.12u as=13.936p ps=54.12u w=53.6u l=0.7u
X506 ESD_RAIL ESD_RAIL a_41764_148611# VSS nfet_06v0 ad=13.936p pd=54.12u as=13.936p ps=54.12u w=53.6u l=0.7u
X507 PULLUP_N_GATE PULLUP_N PULLUP_N_CONTROL_S VSS nfet_06v0 ad=0.88p pd=4.88u as=0.88p ps=4.88u w=2u l=0.7u
X508 a_41764_148611# ESD_RAIL ESD_RAIL VSS nfet_06v0 ad=13.936p pd=54.12u as=13.936p ps=54.12u w=53.6u l=0.7u
X509 a_41764_148611# a_41764_148611# a_41764_160995# VSS nfet_06v0 ad=13.936p pd=54.12u as=13.936p ps=54.12u w=53.6u l=0.7u
X510 FS_N_BLEED_1 FS_N_BLEED_2 VSS ppolyf_u_1k r_width=1u r_length=12.5u
X511 TERM_OR_N_B VCM_LOW_OK TERM_OR_N_S VDD pfet_03v3 ad=1.76p pd=8.88u as=1.76p ps=8.88u w=4u l=0.28u
X512 DIV_N DIV_ENABLE RX_N VSS nfet_06v0 ad=8.8p pd=40.88u as=8.8p ps=40.88u w=20u l=0.7u
X513 a_41005_134065# a_53878_133785# ESD_RAIL ppolyf_u r_width=0.8u r_length=63.855u
X514 a_41764_148611# a_41764_148611# a_41764_160995# VSS nfet_06v0 ad=13.936p pd=54.12u as=13.936p ps=54.12u w=53.6u l=0.7u
X515 a_41764_148611# a_41764_148611# a_41764_160995# VSS nfet_06v0 ad=13.936p pd=54.12u as=13.936p ps=54.12u w=53.6u l=0.7u
X516 FS_P_GATE FS_HIGH_P FS_P_CONTROL_S VSS nfet_06v0 ad=0.88p pd=4.88u as=0.88p ps=4.88u w=2u l=0.7u
X517 VSS a_41764_160995# a_41764_160995# VSS nfet_06v0 ad=23.584p pd=0.10808m as=13.936p ps=54.12u w=53.6u l=0.7u
X518 a_41764_148611# a_41764_148611# a_41764_160995# VSS nfet_06v0 ad=13.936p pd=54.12u as=13.936p ps=54.12u w=53.6u l=0.7u
X519 ESD_RAIL ESD_RAIL a_41764_148611# VSS nfet_06v0 ad=13.936p pd=54.12u as=13.936p ps=54.12u w=53.6u l=0.7u
X520 VDD FS_P_GATE FS_P_WELL FS_P_WELL pfet_03v3 ad=6.16p pd=28.88u as=6.16p ps=28.88u w=14u l=0.28u
X521 HS_P_10 HS_PBIAS VDD VDD pfet_03v3 ad=8.8p pd=40.88u as=8.8p ps=40.88u w=20u l=1u
X522 a_41764_160995# a_41764_148611# a_41764_148611# VSS nfet_06v0 ad=13.936p pd=54.12u as=13.936p ps=54.12u w=53.6u l=0.7u
X523 VSS a_42245_90628# ESD_RAIL VSS nfet_06v0 ad=13p pd=50.52u as=13p ps=50.52u w=50u l=0.7u
X524 ESD_RAIL ESD_RAIL a_41764_148611# VSS nfet_06v0 ad=13.936p pd=54.12u as=13.936p ps=54.12u w=53.6u l=0.7u
X525 ESD_RAIL ESD_RAIL a_41764_148611# VSS nfet_06v0 ad=13.936p pd=54.12u as=13.936p ps=54.12u w=53.6u l=0.7u
X526 VSS a_41764_160995# a_41764_160995# VSS nfet_06v0 ad=13.936p pd=54.12u as=13.936p ps=54.12u w=53.6u l=0.7u
X527 VSS a_41764_160995# a_41764_160995# VSS nfet_06v0 ad=13.936p pd=54.12u as=13.936p ps=54.12u w=53.6u l=0.7u
X528 ESD_RAIL ESD_RAIL a_41764_148611# VSS nfet_06v0 ad=13.936p pd=54.12u as=13.936p ps=54.12u w=53.6u l=0.7u
X529 VSS a_42245_90628# ESD_RAIL VSS nfet_06v0 ad=13p pd=50.52u as=13p ps=50.52u w=50u l=0.7u
X530 ESD_RAIL a_44789_117064# a_42245_90628# ESD_RAIL pfet_06v0 ad=1.3p pd=5.52u as=1.3p ps=5.52u w=5u l=0.7u
X531 TERM_N_R TERM_GATE_N TERM_VCM VSS nfet_03v3 ad=8.8p pd=40.88u as=8.8p ps=40.88u w=20u l=0.28u
X532 VSS a_41764_160995# a_41764_160995# VSS nfet_06v0 ad=13.936p pd=54.12u as=13.936p ps=54.12u w=53.6u l=0.7u
X533 a_41764_148611# a_41764_148611# a_41764_160995# VSS nfet_06v0 ad=13.936p pd=54.12u as=13.936p ps=54.12u w=53.6u l=0.7u
X534 a_41764_148611# ESD_RAIL ESD_RAIL VSS nfet_06v0 ad=13.936p pd=54.12u as=13.936p ps=54.12u w=53.6u l=0.7u
X535 VSS RX_P VSS ppolyf_u_1k_6p0 r_width=1u r_length=0.31954m
X536 ESD_RAIL ESD_RAIL a_41764_148611# VSS nfet_06v0 ad=13.936p pd=54.12u as=23.584p ps=0.10808m w=53.6u l=0.7u
X537 ESD_RAIL a_42245_90628# VSS VSS nfet_06v0 ad=13p pd=50.52u as=13p ps=50.52u w=50u l=0.7u
X538 a_41764_160995# a_41764_148611# a_41764_148611# VSS nfet_06v0 ad=13.936p pd=54.12u as=13.936p ps=54.12u w=53.6u l=0.7u
X539 ESD_RAIL ESD_RAIL a_41764_148611# VSS nfet_06v0 ad=13.936p pd=54.12u as=13.936p ps=54.12u w=53.6u l=0.7u
D12 VSS ESD_RAIL diode_nd2ps_06v0 pj=82u area=40p
X540 VDD FS_P_GATE FS_P_WELL FS_P_WELL pfet_03v3 ad=6.16p pd=28.88u as=6.16p ps=28.88u w=14u l=0.28u
X541 a_41764_160995# a_41764_148611# a_41764_148611# VSS nfet_06v0 ad=23.584p pd=0.10808m as=13.936p ps=54.12u w=53.6u l=0.7u
X542 ESD_RAIL VSS cap_mim_2f0_m4m5_noshield c_width=31.6u c_length=31.6u
X543 a_41764_160995# a_41764_148611# a_41764_148611# VSS nfet_06v0 ad=13.936p pd=54.12u as=13.936p ps=54.12u w=53.6u l=0.7u
X544 a_41764_160995# a_41764_148611# a_41764_148611# VSS nfet_06v0 ad=13.936p pd=54.12u as=13.936p ps=54.12u w=53.6u l=0.7u
X545 ESD_RAIL a_43813_117064# a_44789_117064# ESD_RAIL pfet_06v0 ad=1.3p pd=5.52u as=1.3p ps=5.52u w=5u l=0.7u
X546 ESD_RAIL ESD_RAIL a_41764_148611# VSS nfet_06v0 ad=13.936p pd=54.12u as=13.936p ps=54.12u w=53.6u l=0.7u
X547 a_41764_160995# a_41764_148611# a_41764_148611# VSS nfet_06v0 ad=13.936p pd=54.12u as=13.936p ps=54.12u w=53.6u l=0.7u
X548 VDD FS_P_GATE FS_P_WELL FS_P_WELL pfet_03v3 ad=6.16p pd=28.88u as=6.16p ps=28.88u w=14u l=0.28u
X549 a_41764_148611# ESD_RAIL ESD_RAIL VSS nfet_06v0 ad=13.936p pd=54.12u as=13.936p ps=54.12u w=53.6u l=0.7u
X550 PULLUP_N_OUT PAD_N VSS ppolyf_u_1k r_width=1u r_length=1.18u
X551 VSS a_41764_160995# a_41764_160995# VSS nfet_06v0 ad=23.584p pd=0.10808m as=13.936p ps=54.12u w=53.6u l=0.7u
X552 a_41764_148611# ESD_RAIL ESD_RAIL VSS nfet_06v0 ad=13.936p pd=54.12u as=13.936p ps=54.12u w=53.6u l=0.7u
X553 a_41764_148611# ESD_RAIL ESD_RAIL VSS nfet_06v0 ad=13.936p pd=54.12u as=13.936p ps=54.12u w=53.6u l=0.7u
X554 VDD FS_P_GATE FS_P_WELL FS_P_WELL pfet_03v3 ad=6.16p pd=28.88u as=6.16p ps=28.88u w=14u l=0.28u
X555 a_41764_148611# ESD_RAIL ESD_RAIL VSS nfet_06v0 ad=13.936p pd=54.12u as=13.936p ps=54.12u w=53.6u l=0.7u
X556 FS_N_WELL FS_N_BLEED_0 VSS ppolyf_u_1k r_width=1u r_length=12.5u
X557 a_41764_160995# a_41764_160995# VSS VSS nfet_06v0 ad=13.936p pd=54.12u as=13.936p ps=54.12u w=53.6u l=0.7u
X558 a_41764_160995# a_41764_148611# a_41764_148611# VSS nfet_06v0 ad=13.936p pd=54.12u as=13.936p ps=54.12u w=53.6u l=0.7u
D13 VSS PAD_N diode_nd2ps_06v0 pj=51.8u area=22.5p
X559 a_42245_90628# a_44789_117064# ESD_RAIL ESD_RAIL pfet_06v0 ad=1.3p pd=5.52u as=1.3p ps=5.52u w=5u l=0.7u
X560 a_41764_148611# a_41764_148611# a_41764_160995# VSS nfet_06v0 ad=13.936p pd=54.12u as=13.936p ps=54.12u w=53.6u l=0.7u
X561 a_41764_160995# a_41764_160995# VSS VSS nfet_06v0 ad=13.936p pd=54.12u as=13.936p ps=54.12u w=53.6u l=0.7u
X562 a_41764_160995# a_41764_148611# a_41764_148611# VSS nfet_06v0 ad=13.936p pd=54.12u as=13.936p ps=54.12u w=53.6u l=0.7u
X563 PULLUP_N_GATE VDD PULLUP_N_WELL PULLUP_N_WELL pfet_03v3 ad=1.76p pd=8.88u as=1.76p ps=8.88u w=4u l=0.28u
X564 VSS a_41764_160995# a_41764_160995# VSS nfet_06v0 ad=13.936p pd=54.12u as=13.936p ps=54.12u w=53.6u l=0.7u
X565 VSS a_41764_160995# a_41764_160995# VSS nfet_06v0 ad=13.936p pd=54.12u as=13.936p ps=54.12u w=53.6u l=0.7u
X566 a_41764_148611# a_41764_148611# a_41764_160995# VSS nfet_06v0 ad=13.936p pd=54.12u as=13.936p ps=54.12u w=53.6u l=0.7u
X567 a_41764_148611# ESD_RAIL ESD_RAIL VSS nfet_06v0 ad=13.936p pd=54.12u as=13.936p ps=54.12u w=53.6u l=0.7u
X568 FS_N_OUT FS_N_GATE FS_N_WELL FS_N_WELL pfet_03v3 ad=6.16p pd=28.88u as=6.16p ps=28.88u w=14u l=0.28u
X569 PULLUP_P_WELL PULLUP_P_BLEED_0 VSS ppolyf_u_1k r_width=1u r_length=12.5u
X570 a_41764_148611# ESD_RAIL ESD_RAIL VSS nfet_06v0 ad=13.936p pd=54.12u as=13.936p ps=54.12u w=53.6u l=0.7u
X571 a_41764_160995# a_41764_160995# VSS VSS nfet_06v0 ad=13.936p pd=54.12u as=13.936p ps=54.12u w=53.6u l=0.7u
X572 a_41764_148611# a_41764_148611# a_41764_160995# VSS nfet_06v0 ad=13.936p pd=54.12u as=13.936p ps=54.12u w=53.6u l=0.7u
X573 HS_P_6 HS_PBIAS VDD VDD pfet_03v3 ad=8.8p pd=40.88u as=8.8p ps=40.88u w=20u l=1u
X574 ESD_RAIL ESD_RAIL a_41764_148611# VSS nfet_06v0 ad=13.936p pd=54.12u as=13.936p ps=54.12u w=53.6u l=0.7u
X575 a_43813_117064# a_41005_131545# ESD_RAIL ESD_RAIL pfet_06v0 ad=1.3p pd=5.52u as=2.2p ps=10.88u w=5u l=0.7u
X576 a_41764_148611# ESD_RAIL ESD_RAIL VSS nfet_06v0 ad=13.936p pd=54.12u as=13.936p ps=54.12u w=53.6u l=0.7u
X577 a_41764_160995# a_41764_160995# VSS VSS nfet_06v0 ad=13.936p pd=54.12u as=13.936p ps=54.12u w=53.6u l=0.7u
X578 ESD_RAIL a_42245_90628# VSS VSS nfet_06v0 ad=22p pd=0.10088m as=13p ps=50.52u w=50u l=0.7u
X579 a_41764_148611# ESD_RAIL ESD_RAIL VSS nfet_06v0 ad=13.936p pd=54.12u as=13.936p ps=54.12u w=53.6u l=0.7u
X580 VDD FS_N_GATE FS_N_WELL FS_N_WELL pfet_03v3 ad=6.16p pd=28.88u as=6.16p ps=28.88u w=14u l=0.28u
X581 a_41764_160995# a_41764_160995# VSS VSS nfet_06v0 ad=13.936p pd=54.12u as=13.936p ps=54.12u w=53.6u l=0.7u
X582 ESD_RAIL ESD_RAIL a_41764_148611# VSS nfet_06v0 ad=13.936p pd=54.12u as=13.936p ps=54.12u w=53.6u l=0.7u
X583 ESD_RAIL a_42245_90628# VSS VSS nfet_06v0 ad=13p pd=50.52u as=13p ps=50.52u w=50u l=0.7u
X584 VSS a_42245_90628# ESD_RAIL VSS nfet_06v0 ad=13p pd=50.52u as=13p ps=50.52u w=50u l=0.7u
X585 VDD FS_N_GATE FS_N_WELL FS_N_WELL pfet_03v3 ad=6.16p pd=28.88u as=6.16p ps=28.88u w=14u l=0.28u
X586 VSS a_41764_160995# a_41764_160995# VSS nfet_06v0 ad=13.936p pd=54.12u as=13.936p ps=54.12u w=53.6u l=0.7u
X587 a_41764_160995# a_41764_160995# VSS VSS nfet_06v0 ad=13.936p pd=54.12u as=13.936p ps=54.12u w=53.6u l=0.7u
X588 a_41764_160995# a_41764_148611# a_41764_148611# VSS nfet_06v0 ad=13.936p pd=54.12u as=13.936p ps=54.12u w=53.6u l=0.7u
X589 a_41764_148611# a_41764_148611# a_41764_160995# VSS nfet_06v0 ad=13.936p pd=54.12u as=13.936p ps=54.12u w=53.6u l=0.7u
X590 VSS a_41764_160995# a_41764_160995# VSS nfet_06v0 ad=13.936p pd=54.12u as=13.936p ps=54.12u w=53.6u l=0.7u
X591 VDD FS_P_GATE FS_P_WELL FS_P_WELL pfet_03v3 ad=6.16p pd=28.88u as=6.16p ps=28.88u w=14u l=0.28u
X592 a_41764_148611# a_41764_148611# a_41764_160995# VSS nfet_06v0 ad=13.936p pd=54.12u as=13.936p ps=54.12u w=53.6u l=0.7u
X593 VSS a_42245_90628# ESD_RAIL VSS nfet_06v0 ad=13p pd=50.52u as=13p ps=50.52u w=50u l=0.7u
X594 a_44789_117064# a_43813_117064# ESD_RAIL ESD_RAIL pfet_06v0 ad=1.3p pd=5.52u as=1.3p ps=5.52u w=5u l=0.7u
X595 ESD_RAIL ESD_RAIL a_41764_148611# VSS nfet_06v0 ad=13.936p pd=54.12u as=13.936p ps=54.12u w=53.6u l=0.7u
X596 VDD FS_P_GATE FS_P_WELL FS_P_WELL pfet_03v3 ad=6.16p pd=28.88u as=6.16p ps=28.88u w=14u l=0.28u
X597 HS_P_12 HS_PBIAS VDD VDD pfet_03v3 ad=8.8p pd=40.88u as=8.8p ps=40.88u w=20u l=1u
X598 ESD_RAIL ESD_RAIL a_41764_148611# VSS nfet_06v0 ad=13.936p pd=54.12u as=13.936p ps=54.12u w=53.6u l=0.7u
X599 ESD_RAIL ESD_RAIL a_41764_148611# VSS nfet_06v0 ad=13.936p pd=54.12u as=13.936p ps=54.12u w=53.6u l=0.7u
X600 a_41764_160995# a_41764_160995# VSS VSS nfet_06v0 ad=13.936p pd=54.12u as=13.936p ps=54.12u w=53.6u l=0.7u
X601 a_41764_160995# a_41764_148611# a_41764_148611# VSS nfet_06v0 ad=13.936p pd=54.12u as=13.936p ps=54.12u w=53.6u l=0.7u
X602 ESD_RAIL ESD_RAIL a_41764_148611# VSS nfet_06v0 ad=13.936p pd=54.12u as=23.584p ps=0.10808m w=53.6u l=0.7u
X603 TERM_P_R DIFF_ENABLE TERM_N_R VSS nfet_03v3 ad=8.8p pd=40.88u as=8.8p ps=40.88u w=20u l=0.28u
X604 ESD_RAIL ESD_RAIL a_41764_148611# VSS nfet_06v0 ad=13.936p pd=54.12u as=13.936p ps=54.12u w=53.6u l=0.7u
X605 VSS a_41764_160995# a_41764_160995# VSS nfet_06v0 ad=13.936p pd=54.12u as=13.936p ps=54.12u w=53.6u l=0.7u
X606 a_41764_148611# ESD_RAIL ESD_RAIL VSS nfet_06v0 ad=13.936p pd=54.12u as=13.936p ps=54.12u w=53.6u l=0.7u
X607 TERM_GATE_N_BLEED_0 TERM_GATE_N_BLEED_1 VSS ppolyf_u_1k r_width=1u r_length=12.5u
X608 a_41764_160995# a_41764_148611# a_41764_148611# VSS nfet_06v0 ad=13.936p pd=54.12u as=13.936p ps=54.12u w=53.6u l=0.7u
X609 a_41764_148611# a_41764_148611# a_41764_160995# VSS nfet_06v0 ad=13.936p pd=54.12u as=13.936p ps=54.12u w=53.6u l=0.7u
X610 a_41764_148611# ESD_RAIL ESD_RAIL VSS nfet_06v0 ad=13.936p pd=54.12u as=13.936p ps=54.12u w=53.6u l=0.7u
X611 PULLUP_P_BLEED_3 PULLUP_P_BLEED_4 VSS ppolyf_u_1k r_width=1u r_length=12.5u
X612 a_41764_160995# a_41764_160995# VSS VSS nfet_06v0 ad=13.936p pd=54.12u as=13.936p ps=54.12u w=53.6u l=0.7u
X613 ESD_RAIL ESD_RAIL a_41764_148611# VSS nfet_06v0 ad=13.936p pd=54.12u as=13.936p ps=54.12u w=53.6u l=0.7u
X614 a_41764_160995# a_41764_160995# VSS VSS nfet_06v0 ad=13.936p pd=54.12u as=13.936p ps=54.12u w=53.6u l=0.7u
X615 VDD FS_N_GATE FS_N_WELL FS_N_WELL pfet_03v3 ad=6.16p pd=28.88u as=6.16p ps=28.88u w=14u l=0.28u
X616 VDD FS_P_GATE FS_P_WELL FS_P_WELL pfet_03v3 ad=6.16p pd=28.88u as=6.16p ps=28.88u w=14u l=0.28u
X617 a_41764_160995# a_41764_148611# a_41764_148611# VSS nfet_06v0 ad=13.936p pd=54.12u as=13.936p ps=54.12u w=53.6u l=0.7u
X618 a_41764_148611# ESD_RAIL ESD_RAIL VSS nfet_06v0 ad=13.936p pd=54.12u as=13.936p ps=54.12u w=53.6u l=0.7u
D14 VSS FS_LOW_N diode_nd2ps_03v3 pj=4.92u area=1.5129p
X619 VSS a_41764_160995# a_41764_160995# VSS nfet_06v0 ad=13.936p pd=54.12u as=13.936p ps=54.12u w=53.6u l=0.7u
X620 VSS a_41764_160995# a_41764_160995# VSS nfet_06v0 ad=13.936p pd=54.12u as=13.936p ps=54.12u w=53.6u l=0.7u
X621 VDD FS_N_GATE FS_N_WELL FS_N_WELL pfet_03v3 ad=6.16p pd=28.88u as=6.16p ps=28.88u w=14u l=0.28u
X622 VSS a_41764_160995# a_41764_160995# VSS nfet_06v0 ad=13.936p pd=54.12u as=13.936p ps=54.12u w=53.6u l=0.7u
X623 a_41764_148611# a_41764_148611# a_41764_160995# VSS nfet_06v0 ad=13.936p pd=54.12u as=13.936p ps=54.12u w=53.6u l=0.7u
X624 TERM_GATE_P TERM_OR_P_B VSS VSS nfet_03v3 ad=1.76p pd=8.88u as=1.76p ps=8.88u w=4u l=0.28u
X625 HS_N_12 HS_PBIAS VDD VDD pfet_03v3 ad=8.8p pd=40.88u as=8.8p ps=40.88u w=20u l=1u
X626 VSS a_42245_90628# ESD_RAIL VSS nfet_06v0 ad=13p pd=50.52u as=22p ps=0.10088m w=50u l=0.7u
X627 ESD_RAIL a_44789_117064# a_42245_90628# ESD_RAIL pfet_06v0 ad=1.3p pd=5.52u as=1.3p ps=5.52u w=5u l=0.7u
X628 HS_N_8 HS_N PAD_N VSS nfet_06v0 ad=8.8p pd=40.88u as=8.8p ps=40.88u w=20u l=0.7u
X629 VSS a_42245_90628# ESD_RAIL VSS nfet_06v0 ad=13p pd=50.52u as=13p ps=50.52u w=50u l=0.7u
X630 PULLUP_N_BLEED_4 PULLUP_N_BLEED_5 VSS ppolyf_u_1k r_width=1u r_length=12.5u
X631 ESD_RAIL ESD_RAIL a_41764_148611# VSS nfet_06v0 ad=13.936p pd=54.12u as=13.936p ps=54.12u w=53.6u l=0.7u
X632 VSS a_42245_90628# ESD_RAIL VSS nfet_06v0 ad=13p pd=50.52u as=13p ps=50.52u w=50u l=0.7u
X633 ESD_RAIL ESD_RAIL a_41764_148611# VSS nfet_06v0 ad=13.936p pd=54.12u as=13.936p ps=54.12u w=53.6u l=0.7u
X634 a_41764_160995# a_41764_148611# a_41764_148611# VSS nfet_06v0 ad=23.584p pd=0.10808m as=13.936p ps=54.12u w=53.6u l=0.7u
X635 a_41764_148611# ESD_RAIL ESD_RAIL VSS nfet_06v0 ad=13.936p pd=54.12u as=13.936p ps=54.12u w=53.6u l=0.7u
X636 TERM_OR_P_B FS_LOW_P TERM_OR_P_S VDD pfet_03v3 ad=1.76p pd=8.88u as=1.76p ps=8.88u w=4u l=0.28u
X637 a_41764_148611# ESD_RAIL ESD_RAIL VSS nfet_06v0 ad=13.936p pd=54.12u as=13.936p ps=54.12u w=53.6u l=0.7u
X638 VDD FS_N_GATE FS_N_WELL FS_N_WELL pfet_03v3 ad=6.16p pd=28.88u as=6.16p ps=28.88u w=14u l=0.28u
X639 a_41764_160995# a_41764_160995# VSS VSS nfet_06v0 ad=13.936p pd=54.12u as=13.936p ps=54.12u w=53.6u l=0.7u
X640 a_41764_160995# a_41764_160995# VSS VSS nfet_06v0 ad=13.936p pd=54.12u as=13.936p ps=54.12u w=53.6u l=0.7u
X641 VSS a_41764_160995# a_41764_160995# VSS nfet_06v0 ad=23.584p pd=0.10808m as=13.936p ps=54.12u w=53.6u l=0.7u
X642 a_41764_160995# a_41764_148611# a_41764_148611# VSS nfet_06v0 ad=13.936p pd=54.12u as=13.936p ps=54.12u w=53.6u l=0.7u
X643 a_41764_160995# a_41764_148611# a_41764_148611# VSS nfet_06v0 ad=13.936p pd=54.12u as=13.936p ps=54.12u w=53.6u l=0.7u
X644 ESD_RAIL ESD_RAIL a_41764_148611# VSS nfet_06v0 ad=13.936p pd=54.12u as=13.936p ps=54.12u w=53.6u l=0.7u
X645 a_41764_160995# a_41764_148611# a_41764_148611# VSS nfet_06v0 ad=13.936p pd=54.12u as=13.936p ps=54.12u w=53.6u l=0.7u
X646 ESD_RAIL ESD_RAIL a_41764_148611# VSS nfet_06v0 ad=13.936p pd=54.12u as=13.936p ps=54.12u w=53.6u l=0.7u
X647 VSS a_41764_160995# a_41764_160995# VSS nfet_06v0 ad=13.936p pd=54.12u as=13.936p ps=54.12u w=53.6u l=0.7u
X648 a_41764_148611# ESD_RAIL ESD_RAIL VSS nfet_06v0 ad=13.936p pd=54.12u as=13.936p ps=54.12u w=53.6u l=0.7u
X649 TERM_GATE_P TERM_OR_P_B VDD VDD pfet_03v3 ad=3.52p pd=16.88u as=3.52p ps=16.88u w=8u l=0.28u
X650 a_41764_160995# a_41764_160995# VSS VSS nfet_06v0 ad=13.936p pd=54.12u as=13.936p ps=54.12u w=53.6u l=0.7u
X651 VSS RX_N VSS ppolyf_u_1k_6p0 r_width=1u r_length=0.31954m
X652 HS_N_10 HS_PBIAS VDD VDD pfet_03v3 ad=8.8p pd=40.88u as=8.8p ps=40.88u w=20u l=1u
X653 ESD_RAIL ESD_RAIL a_41764_148611# VSS nfet_06v0 ad=13.936p pd=54.12u as=13.936p ps=54.12u w=53.6u l=0.7u
D15 PAD_P ESD_RAIL diode_pd2nw_06v0 pj=51.8u area=22.5p
X654 TERM_OR_P_B FS_LOW_P TERM_OR_P_NS VSS nfet_03v3 ad=0.88p pd=4.88u as=0.88p ps=4.88u w=2u l=0.28u
X655 FS_N_BLEED_3 FS_N_BLEED_4 VSS ppolyf_u_1k r_width=1u r_length=12.5u
X656 a_41764_160995# a_41764_148611# a_41764_148611# VSS nfet_06v0 ad=23.584p pd=0.10808m as=13.936p ps=54.12u w=53.6u l=0.7u
X657 ESD_RAIL a_42245_90628# VSS VSS nfet_06v0 ad=13p pd=50.52u as=13p ps=50.52u w=50u l=0.7u
X658 a_41764_148611# a_41764_148611# a_41764_160995# VSS nfet_06v0 ad=13.936p pd=54.12u as=13.936p ps=54.12u w=53.6u l=0.7u
X659 a_41764_148611# ESD_RAIL ESD_RAIL VSS nfet_06v0 ad=13.936p pd=54.12u as=13.936p ps=54.12u w=53.6u l=0.7u
X660 PULLUP_N_BLEED_0 PULLUP_N_BLEED_1 VSS ppolyf_u_1k r_width=1u r_length=12.5u
D16 VSS FS_LOW_P diode_nd2ps_03v3 pj=8.76u area=4.7961p
X661 FS_P_BLEED_4 FS_P_BLEED_5 VSS ppolyf_u_1k r_width=1u r_length=12.5u
X662 VSS a_42245_90628# ESD_RAIL VSS nfet_06v0 ad=13p pd=50.52u as=13p ps=50.52u w=50u l=0.7u
X663 a_41764_148611# ESD_RAIL ESD_RAIL VSS nfet_06v0 ad=23.584p pd=0.10808m as=13.936p ps=54.12u w=53.6u l=0.7u
X664 FS_P_OUT FS_P_GATE FS_P_WELL FS_P_WELL pfet_03v3 ad=6.16p pd=28.88u as=6.16p ps=28.88u w=14u l=0.28u
X665 a_41764_148611# ESD_RAIL ESD_RAIL VSS nfet_06v0 ad=13.936p pd=54.12u as=13.936p ps=54.12u w=53.6u l=0.7u
X666 VSS a_43813_117064# a_44789_117064# VSS nfet_06v0 ad=1.3p pd=5.52u as=1.3p ps=5.52u w=5u l=0.7u
X667 VDD PULLUP_P_GATE PULLUP_P_WELL PULLUP_P_WELL pfet_03v3 ad=8.8p pd=40.88u as=8.8p ps=40.88u w=20u l=0.28u
X668 a_41764_148611# a_41764_148611# a_41764_160995# VSS nfet_06v0 ad=13.936p pd=54.12u as=13.936p ps=54.12u w=53.6u l=0.7u
X669 FS_N_BLEED_5 FS_N_BLEED_6 VSS ppolyf_u_1k r_width=1u r_length=12.5u
X670 a_41764_160995# a_41764_148611# a_41764_148611# VSS nfet_06v0 ad=13.936p pd=54.12u as=13.936p ps=54.12u w=53.6u l=0.7u
X671 ESD_RAIL ESD_RAIL a_41764_148611# VSS nfet_06v0 ad=13.936p pd=54.12u as=13.936p ps=54.12u w=53.6u l=0.7u
X672 VDD FS_N_GATE FS_N_WELL FS_N_WELL pfet_03v3 ad=6.16p pd=28.88u as=6.16p ps=28.88u w=14u l=0.28u
X673 VSS a_41764_160995# a_41764_160995# VSS nfet_06v0 ad=13.936p pd=54.12u as=13.936p ps=54.12u w=53.6u l=0.7u
X674 a_41764_160995# a_41764_160995# VSS VSS nfet_06v0 ad=13.936p pd=54.12u as=13.936p ps=54.12u w=53.6u l=0.7u
X675 a_41764_160995# a_41764_160995# VSS VSS nfet_06v0 ad=13.936p pd=54.12u as=13.936p ps=54.12u w=53.6u l=0.7u
X676 a_41764_160995# a_41764_148611# a_41764_148611# VSS nfet_06v0 ad=13.936p pd=54.12u as=13.936p ps=54.12u w=53.6u l=0.7u
X677 ESD_RAIL ESD_RAIL a_41764_148611# VSS nfet_06v0 ad=13.936p pd=54.12u as=13.936p ps=54.12u w=53.6u l=0.7u
X678 VSS a_41764_160995# a_41764_160995# VSS nfet_06v0 ad=13.936p pd=54.12u as=13.936p ps=54.12u w=53.6u l=0.7u
X679 a_41764_148611# a_41764_148611# a_41764_160995# VSS nfet_06v0 ad=13.936p pd=54.12u as=13.936p ps=54.12u w=53.6u l=0.7u
X680 ESD_RAIL a_42245_90628# VSS VSS nfet_06v0 ad=22p pd=0.10088m as=13p ps=50.52u w=50u l=0.7u
X681 HS_N_1 HS_N PAD_N VSS nfet_06v0 ad=8.8p pd=40.88u as=8.8p ps=40.88u w=20u l=0.7u
X682 a_41764_148611# ESD_RAIL ESD_RAIL VSS nfet_06v0 ad=13.936p pd=54.12u as=13.936p ps=54.12u w=53.6u l=0.7u
X683 VSS a_42245_90628# ESD_RAIL VSS nfet_06v0 ad=13p pd=50.52u as=13p ps=50.52u w=50u l=0.7u
X684 a_41764_148611# a_41764_148611# a_41764_160995# VSS nfet_06v0 ad=13.936p pd=54.12u as=13.936p ps=54.12u w=53.6u l=0.7u
X685 ESD_RAIL ESD_RAIL a_41764_148611# VSS nfet_06v0 ad=13.936p pd=54.12u as=23.584p ps=0.10808m w=53.6u l=0.7u
X686 HS_N_4 HS_PBIAS VDD VDD pfet_03v3 ad=8.8p pd=40.88u as=8.8p ps=40.88u w=20u l=1u
X687 a_41764_148611# a_41764_148611# a_41764_160995# VSS nfet_06v0 ad=13.936p pd=54.12u as=13.936p ps=54.12u w=53.6u l=0.7u
D17 VSS PAD_P diode_nd2ps_06v0 pj=51.8u area=22.5p
X688 FS_N_GATE FS_HIGH_N FS_N_CONTROL_S VSS nfet_06v0 ad=0.88p pd=4.88u as=0.88p ps=4.88u w=2u l=0.7u
X689 a_41764_160995# a_41764_148611# a_41764_148611# VSS nfet_06v0 ad=13.936p pd=54.12u as=13.936p ps=54.12u w=53.6u l=0.7u
X690 VSS a_44789_117064# a_42245_90628# VSS nfet_06v0 ad=1.3p pd=5.52u as=1.3p ps=5.52u w=5u l=0.7u
X691 ESD_RAIL ESD_RAIL a_41764_148611# VSS nfet_06v0 ad=13.936p pd=54.12u as=13.936p ps=54.12u w=53.6u l=0.7u
X692 VDD FS_N_GATE FS_N_WELL FS_N_WELL pfet_03v3 ad=6.16p pd=28.88u as=6.16p ps=28.88u w=14u l=0.28u
X693 a_41764_148611# a_41764_148611# a_41764_160995# VSS nfet_06v0 ad=13.936p pd=54.12u as=13.936p ps=54.12u w=53.6u l=0.7u
X694 ESD_RAIL ESD_RAIL a_41764_148611# VSS nfet_06v0 ad=13.936p pd=54.12u as=13.936p ps=54.12u w=53.6u l=0.7u
X695 a_41764_160995# a_41764_160995# VSS VSS nfet_06v0 ad=13.936p pd=54.12u as=13.936p ps=54.12u w=53.6u l=0.7u
X696 a_41764_160995# a_41764_148611# a_41764_148611# VSS nfet_06v0 ad=13.936p pd=54.12u as=13.936p ps=54.12u w=53.6u l=0.7u
X697 VSS a_44789_117064# a_42245_90628# VSS nfet_06v0 ad=1.3p pd=5.52u as=1.3p ps=5.52u w=5u l=0.7u
X698 TERM_GATE_N TERM_OR_N_B VSS VSS nfet_03v3 ad=1.76p pd=8.88u as=1.76p ps=8.88u w=4u l=0.28u
X699 a_41764_148611# ESD_RAIL ESD_RAIL VSS nfet_06v0 ad=13.936p pd=54.12u as=13.936p ps=54.12u w=53.6u l=0.7u
X700 a_41764_160995# a_41764_160995# VSS VSS nfet_06v0 ad=13.936p pd=54.12u as=13.936p ps=54.12u w=53.6u l=0.7u
X701 VSS a_41764_160995# a_41764_160995# VSS nfet_06v0 ad=13.936p pd=54.12u as=13.936p ps=54.12u w=53.6u l=0.7u
X702 a_41764_148611# ESD_RAIL ESD_RAIL VSS nfet_06v0 ad=13.936p pd=54.12u as=13.936p ps=54.12u w=53.6u l=0.7u
X703 ESD_RAIL a_44789_117064# a_42245_90628# ESD_RAIL pfet_06v0 ad=1.3p pd=5.52u as=1.3p ps=5.52u w=5u l=0.7u
X704 a_41764_148611# ESD_RAIL ESD_RAIL VSS nfet_06v0 ad=23.584p pd=0.10808m as=13.936p ps=54.12u w=53.6u l=0.7u
X705 a_41764_160995# a_41764_160995# VSS VSS nfet_06v0 ad=13.936p pd=54.12u as=13.936p ps=54.12u w=53.6u l=0.7u
X706 VSS a_41764_160995# a_41764_160995# VSS nfet_06v0 ad=23.584p pd=0.10808m as=13.936p ps=54.12u w=53.6u l=0.7u
X707 a_41764_160995# a_41764_160995# VSS VSS nfet_06v0 ad=13.936p pd=54.12u as=13.936p ps=54.12u w=53.6u l=0.7u
X708 a_41764_148611# a_41764_148611# a_41764_160995# VSS nfet_06v0 ad=13.936p pd=54.12u as=13.936p ps=54.12u w=53.6u l=0.7u
X709 ESD_RAIL ESD_RAIL a_41764_148611# VSS nfet_06v0 ad=13.936p pd=54.12u as=13.936p ps=54.12u w=53.6u l=0.7u
X710 a_41005_131545# a_53878_131545# ESD_RAIL ppolyf_u r_width=0.8u r_length=63.855u
X711 VSS a_42245_90628# ESD_RAIL VSS nfet_06v0 ad=13p pd=50.52u as=13p ps=50.52u w=50u l=0.7u
X712 HS_N_10 HS_N PAD_N VSS nfet_06v0 ad=8.8p pd=40.88u as=8.8p ps=40.88u w=20u l=0.7u
X713 a_41764_160995# a_41764_148611# a_41764_148611# VSS nfet_06v0 ad=13.936p pd=54.12u as=13.936p ps=54.12u w=53.6u l=0.7u
X714 VSS a_41764_160995# a_41764_160995# VSS nfet_06v0 ad=13.936p pd=54.12u as=13.936p ps=54.12u w=53.6u l=0.7u
X715 VSS a_41764_160995# a_41764_160995# VSS nfet_06v0 ad=13.936p pd=54.12u as=13.936p ps=54.12u w=53.6u l=0.7u
X716 PAD_N BYPASS_ENABLE RX_N VSS nfet_06v0 ad=8.8p pd=40.88u as=8.8p ps=40.88u w=20u l=0.7u
X717 TERM_P_R TERM_GATE_P TERM_VCM VSS nfet_03v3 ad=8.8p pd=40.88u as=8.8p ps=40.88u w=20u l=0.28u
X718 VDD FS_N_GATE FS_N_WELL FS_N_WELL pfet_03v3 ad=6.16p pd=28.88u as=6.16p ps=28.88u w=14u l=0.28u
X719 ESD_RAIL a_42245_90628# VSS VSS nfet_06v0 ad=13p pd=50.52u as=13p ps=50.52u w=50u l=0.7u
D18 PAD_N ESD_RAIL diode_pd2nw_06v0 pj=51.8u area=22.5p
X720 VSS a_41764_160995# a_41764_160995# VSS nfet_06v0 ad=13.936p pd=54.12u as=13.936p ps=54.12u w=53.6u l=0.7u
X721 a_41764_148611# a_41764_148611# a_41764_160995# VSS nfet_06v0 ad=13.936p pd=54.12u as=13.936p ps=54.12u w=53.6u l=0.7u
X722 a_41764_148611# a_41764_148611# a_41764_160995# VSS nfet_06v0 ad=13.936p pd=54.12u as=13.936p ps=54.12u w=53.6u l=0.7u
X723 a_44789_117064# a_43813_117064# VSS VSS nfet_06v0 ad=1.3p pd=5.52u as=1.3p ps=5.52u w=5u l=0.7u
X724 a_41764_160995# a_41764_160995# VSS VSS nfet_06v0 ad=13.936p pd=54.12u as=13.936p ps=54.12u w=53.6u l=0.7u
X725 VSS a_41764_160995# a_41764_160995# VSS nfet_06v0 ad=13.936p pd=54.12u as=13.936p ps=54.12u w=53.6u l=0.7u
X726 ESD_RAIL a_42245_90628# VSS VSS nfet_06v0 ad=13p pd=50.52u as=13p ps=50.52u w=50u l=0.7u
X727 HS_N_3 HS_N PAD_N VSS nfet_06v0 ad=8.8p pd=40.88u as=8.8p ps=40.88u w=20u l=0.7u
X728 VDD FS_N_GATE FS_N_WELL FS_N_WELL pfet_03v3 ad=6.16p pd=28.88u as=6.16p ps=28.88u w=14u l=0.28u
X729 ESD_RAIL ESD_RAIL a_41764_148611# VSS nfet_06v0 ad=13.936p pd=54.12u as=13.936p ps=54.12u w=53.6u l=0.7u
X730 ESD_RAIL ESD_RAIL a_41764_148611# VSS nfet_06v0 ad=13.936p pd=54.12u as=13.936p ps=54.12u w=53.6u l=0.7u
X731 a_41764_160995# a_41764_148611# a_41764_148611# VSS nfet_06v0 ad=13.936p pd=54.12u as=13.936p ps=54.12u w=53.6u l=0.7u
X732 a_41764_160995# a_41764_148611# a_41764_148611# VSS nfet_06v0 ad=13.936p pd=54.12u as=13.936p ps=54.12u w=53.6u l=0.7u
X733 PULLUP_N_OUT PULLUP_N_GATE PULLUP_N_WELL PULLUP_N_WELL pfet_03v3 ad=8.8p pd=40.88u as=8.8p ps=40.88u w=20u l=0.28u
X734 VDD FS_N_GATE FS_N_WELL FS_N_WELL pfet_03v3 ad=6.16p pd=28.88u as=6.16p ps=28.88u w=14u l=0.28u
X735 FS_P_OUT FS_P_GATE FS_P_WELL FS_P_WELL pfet_03v3 ad=6.16p pd=28.88u as=6.16p ps=28.88u w=14u l=0.28u
X736 a_41764_160995# a_41764_148611# a_41764_148611# VSS nfet_06v0 ad=13.936p pd=54.12u as=13.936p ps=54.12u w=53.6u l=0.7u
X737 VSS a_42245_90628# ESD_RAIL VSS nfet_06v0 ad=13p pd=50.52u as=13p ps=50.52u w=50u l=0.7u
X738 a_41764_148611# ESD_RAIL ESD_RAIL VSS nfet_06v0 ad=13.936p pd=54.12u as=13.936p ps=54.12u w=53.6u l=0.7u
X739 VSS a_41764_160995# a_41764_160995# VSS nfet_06v0 ad=23.584p pd=0.10808m as=13.936p ps=54.12u w=53.6u l=0.7u
X740 a_41764_148611# ESD_RAIL ESD_RAIL VSS nfet_06v0 ad=13.936p pd=54.12u as=13.936p ps=54.12u w=53.6u l=0.7u
X741 VDD FS_N_GATE FS_N_WELL FS_N_WELL pfet_03v3 ad=6.16p pd=28.88u as=6.16p ps=28.88u w=14u l=0.28u
X742 a_41764_148611# ESD_RAIL ESD_RAIL VSS nfet_06v0 ad=13.936p pd=54.12u as=13.936p ps=54.12u w=53.6u l=0.7u
X743 ESD_RAIL ESD_RAIL a_41764_148611# VSS nfet_06v0 ad=13.936p pd=54.12u as=13.936p ps=54.12u w=53.6u l=0.7u
X744 a_41764_160995# a_41764_160995# VSS VSS nfet_06v0 ad=13.936p pd=54.12u as=13.936p ps=54.12u w=53.6u l=0.7u
X745 a_41764_160995# a_41764_160995# VSS VSS nfet_06v0 ad=13.936p pd=54.12u as=13.936p ps=54.12u w=53.6u l=0.7u
X746 TERM_N_R TERM_GATE_N TERM_VCM VSS nfet_03v3 ad=8.8p pd=40.88u as=8.8p ps=40.88u w=20u l=0.28u
X747 ESD_RAIL ESD_RAIL a_41764_148611# VSS nfet_06v0 ad=13.936p pd=54.12u as=13.936p ps=54.12u w=53.6u l=0.7u
X748 a_41764_160995# a_41764_160995# VSS VSS nfet_06v0 ad=13.936p pd=54.12u as=23.584p ps=0.10808m w=53.6u l=0.7u
X749 VDD FS_N_GATE FS_N_WELL FS_N_WELL pfet_03v3 ad=6.16p pd=28.88u as=6.16p ps=28.88u w=14u l=0.28u
X750 VSS a_41764_160995# a_41764_160995# VSS nfet_06v0 ad=13.936p pd=54.12u as=13.936p ps=54.12u w=53.6u l=0.7u
X751 a_41005_132385# a_53878_132665# ESD_RAIL ppolyf_u r_width=0.8u r_length=63.855u
X752 a_41764_148611# a_41764_148611# a_41764_160995# VSS nfet_06v0 ad=13.936p pd=54.12u as=13.936p ps=54.12u w=53.6u l=0.7u
X753 a_41764_160995# a_41764_160995# VSS VSS nfet_06v0 ad=13.936p pd=54.12u as=13.936p ps=54.12u w=53.6u l=0.7u
X754 a_41764_148611# a_41764_148611# a_41764_160995# VSS nfet_06v0 ad=13.936p pd=54.12u as=13.936p ps=54.12u w=53.6u l=0.7u
X755 a_41764_160995# a_41764_148611# a_41764_148611# VSS nfet_06v0 ad=23.584p pd=0.10808m as=13.936p ps=54.12u w=53.6u l=0.7u
X756 a_41764_148611# ESD_RAIL ESD_RAIL VSS nfet_06v0 ad=13.936p pd=54.12u as=13.936p ps=54.12u w=53.6u l=0.7u
X757 a_41764_160995# a_41764_160995# VSS VSS nfet_06v0 ad=13.936p pd=54.12u as=13.936p ps=54.12u w=53.6u l=0.7u
X758 a_41764_160995# a_41764_148611# a_41764_148611# VSS nfet_06v0 ad=13.936p pd=54.12u as=13.936p ps=54.12u w=53.6u l=0.7u
X759 ESD_RAIL ESD_RAIL a_41764_148611# VSS nfet_06v0 ad=13.936p pd=54.12u as=13.936p ps=54.12u w=53.6u l=0.7u
X760 VSS a_41764_160995# a_41764_160995# VSS nfet_06v0 ad=13.936p pd=54.12u as=13.936p ps=54.12u w=53.6u l=0.7u
X761 a_41764_148611# ESD_RAIL ESD_RAIL VSS nfet_06v0 ad=13.936p pd=54.12u as=13.936p ps=54.12u w=53.6u l=0.7u
X762 TERM_OR_N_B FS_LOW_N TERM_OR_N_S VDD pfet_03v3 ad=1.76p pd=8.88u as=1.76p ps=8.88u w=4u l=0.28u
X763 FS_P_OUT FS_P_GATE FS_P_WELL FS_P_WELL pfet_03v3 ad=6.16p pd=28.88u as=6.16p ps=28.88u w=14u l=0.28u
X764 a_41764_148611# a_41764_148611# a_41764_160995# VSS nfet_06v0 ad=13.936p pd=54.12u as=13.936p ps=54.12u w=53.6u l=0.7u
X765 VSS a_42245_90628# ESD_RAIL VSS nfet_06v0 ad=13p pd=50.52u as=13p ps=50.52u w=50u l=0.7u
X766 HS_N_0 HS_PBIAS VDD VDD pfet_03v3 ad=8.8p pd=40.88u as=8.8p ps=40.88u w=20u l=1u
X767 a_41764_148611# ESD_RAIL ESD_RAIL VSS nfet_06v0 ad=13.936p pd=54.12u as=13.936p ps=54.12u w=53.6u l=0.7u
X768 PULLUP_P_GATE VDD PULLUP_P_WELL PULLUP_P_WELL pfet_03v3 ad=1.76p pd=8.88u as=1.76p ps=8.88u w=4u l=0.28u
X769 FS_P_OUT FS_P_GATE FS_P_WELL FS_P_WELL pfet_03v3 ad=6.16p pd=28.88u as=6.16p ps=28.88u w=14u l=0.28u
X770 ESD_RAIL ESD_RAIL a_41764_148611# VSS nfet_06v0 ad=13.936p pd=54.12u as=13.936p ps=54.12u w=53.6u l=0.7u
X771 VSS a_42245_90628# ESD_RAIL VSS nfet_06v0 ad=13p pd=50.52u as=13p ps=50.52u w=50u l=0.7u
X772 ESD_RAIL ESD_RAIL a_41764_148611# VSS nfet_06v0 ad=13.936p pd=54.12u as=13.936p ps=54.12u w=53.6u l=0.7u
X773 HS_P_1 HS_PBIAS VDD VDD pfet_03v3 ad=8.8p pd=40.88u as=8.8p ps=40.88u w=20u l=1u
X774 PULLUP_P_BLEED_0 PULLUP_P_BLEED_1 VSS ppolyf_u_1k r_width=1u r_length=12.5u
X775 VSS a_41764_160995# a_41764_160995# VSS nfet_06v0 ad=13.936p pd=54.12u as=13.936p ps=54.12u w=53.6u l=0.7u
X776 PULLUP_N_CONTROL_S VDD VSS VSS nfet_03v3 ad=1.76p pd=8.88u as=1.76p ps=8.88u w=4u l=0.28u
X777 ESD_RAIL a_42245_90628# VSS VSS nfet_06v0 ad=13p pd=50.52u as=13p ps=50.52u w=50u l=0.7u
X778 ESD_RAIL ESD_RAIL a_41764_148611# VSS nfet_06v0 ad=13.936p pd=54.12u as=23.584p ps=0.10808m w=53.6u l=0.7u
X779 ESD_RAIL ESD_RAIL a_41764_148611# VSS nfet_06v0 ad=13.936p pd=54.12u as=13.936p ps=54.12u w=53.6u l=0.7u
X780 VSS a_41764_160995# a_41764_160995# VSS nfet_06v0 ad=13.936p pd=54.12u as=13.936p ps=54.12u w=53.6u l=0.7u
X781 VDD FS_N_GATE FS_N_WELL FS_N_WELL pfet_03v3 ad=6.16p pd=28.88u as=6.16p ps=28.88u w=14u l=0.28u
X782 PULLUP_P_BLEED_6 PULLUP_P_GATE VSS ppolyf_u_1k r_width=1u r_length=12.5u
X783 a_41764_160995# a_41764_148611# a_41764_148611# VSS nfet_06v0 ad=13.936p pd=54.12u as=13.936p ps=54.12u w=53.6u l=0.7u
X784 a_41764_148611# a_41764_148611# a_41764_160995# VSS nfet_06v0 ad=13.936p pd=54.12u as=13.936p ps=54.12u w=53.6u l=0.7u
X785 a_41764_148611# a_41764_148611# a_41764_160995# VSS nfet_06v0 ad=13.936p pd=54.12u as=13.936p ps=54.12u w=53.6u l=0.7u
X786 HS_P_0 HS_P PAD_P VSS nfet_06v0 ad=8.8p pd=40.88u as=8.8p ps=40.88u w=20u l=0.7u
X787 VDD FS_N_GATE FS_N_WELL FS_N_WELL pfet_03v3 ad=6.16p pd=28.88u as=6.16p ps=28.88u w=14u l=0.28u
X788 a_41764_160995# a_41764_160995# VSS VSS nfet_06v0 ad=13.936p pd=54.12u as=13.936p ps=54.12u w=53.6u l=0.7u
X789 a_41764_160995# a_41764_160995# VSS VSS nfet_06v0 ad=13.936p pd=54.12u as=13.936p ps=54.12u w=53.6u l=0.7u
X790 FS_P_OUT FS_P_GATE FS_P_WELL FS_P_WELL pfet_03v3 ad=6.16p pd=28.88u as=6.16p ps=28.88u w=14u l=0.28u
X791 a_41764_160995# a_41764_148611# a_41764_148611# VSS nfet_06v0 ad=13.936p pd=54.12u as=13.936p ps=54.12u w=53.6u l=0.7u
X792 ESD_RAIL ESD_RAIL a_41764_148611# VSS nfet_06v0 ad=13.936p pd=54.12u as=13.936p ps=54.12u w=53.6u l=0.7u
D19 PAD_N ESD_RAIL diode_pd2nw_06v0 pj=51.8u area=22.5p
X793 PAD_P BYPASS_ENABLE RX_P VSS nfet_06v0 ad=8.8p pd=40.88u as=8.8p ps=40.88u w=20u l=0.7u
X794 VDD FS_N_GATE FS_N_WELL FS_N_WELL pfet_03v3 ad=6.16p pd=28.88u as=6.16p ps=28.88u w=14u l=0.28u
X795 FS_P_OUT FS_P_GATE FS_P_WELL FS_P_WELL pfet_03v3 ad=6.16p pd=28.88u as=6.16p ps=28.88u w=14u l=0.28u
X796 a_41764_148611# ESD_RAIL ESD_RAIL VSS nfet_06v0 ad=13.936p pd=54.12u as=13.936p ps=54.12u w=53.6u l=0.7u
X797 a_41005_133505# a_53878_133785# ESD_RAIL ppolyf_u r_width=0.8u r_length=63.855u
X798 a_41764_148611# ESD_RAIL ESD_RAIL VSS nfet_06v0 ad=13.936p pd=54.12u as=13.936p ps=54.12u w=53.6u l=0.7u
X799 a_41764_160995# a_41764_160995# VSS VSS nfet_06v0 ad=13.936p pd=54.12u as=13.936p ps=54.12u w=53.6u l=0.7u
X800 VDD PULLUP_P_GATE PULLUP_P_WELL PULLUP_P_WELL pfet_03v3 ad=8.8p pd=40.88u as=8.8p ps=40.88u w=20u l=0.28u
X801 ESD_RAIL ESD_RAIL a_41764_148611# VSS nfet_06v0 ad=13.936p pd=54.12u as=13.936p ps=54.12u w=53.6u l=0.7u
X802 ESD_RAIL a_42245_90628# VSS VSS nfet_06v0 ad=13p pd=50.52u as=13p ps=50.52u w=50u l=0.7u
X803 a_41764_148611# a_41764_148611# a_41764_160995# VSS nfet_06v0 ad=13.936p pd=54.12u as=13.936p ps=54.12u w=53.6u l=0.7u
X804 PAD_P BYPASS_ENABLE RX_P VSS nfet_06v0 ad=8.8p pd=40.88u as=8.8p ps=40.88u w=20u l=0.7u
X805 VDD FS_N_GATE FS_N_WELL FS_N_WELL pfet_03v3 ad=6.16p pd=28.88u as=6.16p ps=28.88u w=14u l=0.28u
X806 ESD_RAIL a_42245_90628# VSS VSS nfet_06v0 ad=13p pd=50.52u as=13p ps=50.52u w=50u l=0.7u
X807 VSS a_41764_160995# a_41764_160995# VSS nfet_06v0 ad=13.936p pd=54.12u as=13.936p ps=54.12u w=53.6u l=0.7u
X808 VSS a_41764_160995# a_41764_160995# VSS nfet_06v0 ad=13.936p pd=54.12u as=13.936p ps=54.12u w=53.6u l=0.7u
X809 a_41764_148611# a_41764_148611# a_41764_160995# VSS nfet_06v0 ad=13.936p pd=54.12u as=13.936p ps=54.12u w=53.6u l=0.7u
X810 a_41764_160995# a_41764_148611# a_41764_148611# VSS nfet_06v0 ad=13.936p pd=54.12u as=13.936p ps=54.12u w=53.6u l=0.7u
X811 VSS a_42245_90628# ESD_RAIL VSS nfet_06v0 ad=13p pd=50.52u as=13p ps=50.52u w=50u l=0.7u
X812 a_41764_148611# a_41764_148611# a_41764_160995# VSS nfet_06v0 ad=13.936p pd=54.12u as=13.936p ps=54.12u w=53.6u l=0.7u
X813 a_41764_160995# a_41764_148611# a_41764_148611# VSS nfet_06v0 ad=23.584p pd=0.10808m as=13.936p ps=54.12u w=53.6u l=0.7u
X814 a_41764_148611# a_41764_148611# a_41764_160995# VSS nfet_06v0 ad=13.936p pd=54.12u as=13.936p ps=54.12u w=53.6u l=0.7u
X815 HS_P_5 HS_PBIAS VDD VDD pfet_03v3 ad=8.8p pd=40.88u as=8.8p ps=40.88u w=20u l=1u
X816 a_41764_148611# ESD_RAIL ESD_RAIL VSS nfet_06v0 ad=13.936p pd=54.12u as=13.936p ps=54.12u w=53.6u l=0.7u
X817 ESD_RAIL a_44789_117064# a_42245_90628# ESD_RAIL pfet_06v0 ad=1.3p pd=5.52u as=1.3p ps=5.52u w=5u l=0.7u
X818 a_41764_148611# ESD_RAIL ESD_RAIL VSS nfet_06v0 ad=13.936p pd=54.12u as=13.936p ps=54.12u w=53.6u l=0.7u
X819 a_41764_160995# a_41764_160995# VSS VSS nfet_06v0 ad=13.936p pd=54.12u as=13.936p ps=54.12u w=53.6u l=0.7u
X820 a_41764_148611# ESD_RAIL ESD_RAIL VSS nfet_06v0 ad=13.936p pd=54.12u as=13.936p ps=54.12u w=53.6u l=0.7u
D20 VSS PULLDOWN_P diode_nd2ps_03v3 pj=4.92u area=1.5129p
X821 VSS a_42245_90628# ESD_RAIL VSS nfet_06v0 ad=13p pd=50.52u as=13p ps=50.52u w=50u l=0.7u
X822 ESD_RAIL ESD_RAIL a_41764_148611# VSS nfet_06v0 ad=13.936p pd=54.12u as=13.936p ps=54.12u w=53.6u l=0.7u
X823 a_41764_160995# a_41764_148611# a_41764_148611# VSS nfet_06v0 ad=13.936p pd=54.12u as=13.936p ps=54.12u w=53.6u l=0.7u
X824 a_41764_160995# a_41764_160995# VSS VSS nfet_06v0 ad=13.936p pd=54.12u as=13.936p ps=54.12u w=53.6u l=0.7u
X825 a_41764_160995# a_41764_148611# a_41764_148611# VSS nfet_06v0 ad=13.936p pd=54.12u as=13.936p ps=54.12u w=53.6u l=0.7u
X826 VSS a_41764_160995# a_41764_160995# VSS nfet_06v0 ad=23.584p pd=0.10808m as=13.936p ps=54.12u w=53.6u l=0.7u
X827 FS_P_OUT FS_P_GATE FS_P_WELL FS_P_WELL pfet_03v3 ad=6.16p pd=28.88u as=6.16p ps=28.88u w=14u l=0.28u
X828 a_41764_148611# ESD_RAIL ESD_RAIL VSS nfet_06v0 ad=13.936p pd=54.12u as=13.936p ps=54.12u w=53.6u l=0.7u
X829 HS_P_8 HS_P PAD_P VSS nfet_06v0 ad=8.8p pd=40.88u as=8.8p ps=40.88u w=20u l=0.7u
X830 a_41764_148611# a_41764_148611# a_41764_160995# VSS nfet_06v0 ad=13.936p pd=54.12u as=13.936p ps=54.12u w=53.6u l=0.7u
X831 a_41764_160995# a_41764_148611# a_41764_148611# VSS nfet_06v0 ad=13.936p pd=54.12u as=13.936p ps=54.12u w=53.6u l=0.7u
X832 a_41764_160995# a_41764_148611# a_41764_148611# VSS nfet_06v0 ad=13.936p pd=54.12u as=13.936p ps=54.12u w=53.6u l=0.7u
X833 VSS a_41764_160995# a_41764_160995# VSS nfet_06v0 ad=13.936p pd=54.12u as=13.936p ps=54.12u w=53.6u l=0.7u
X834 a_44789_117064# a_43813_117064# VSS VSS nfet_06v0 ad=1.3p pd=5.52u as=1.3p ps=5.52u w=5u l=0.7u
X835 VSS a_41764_160995# a_41764_160995# VSS nfet_06v0 ad=13.936p pd=54.12u as=13.936p ps=54.12u w=53.6u l=0.7u
X836 FS_P_OUT FS_P_GATE FS_P_WELL FS_P_WELL pfet_03v3 ad=6.16p pd=28.88u as=6.16p ps=28.88u w=14u l=0.28u
X837 a_41764_148611# ESD_RAIL ESD_RAIL VSS nfet_06v0 ad=13.936p pd=54.12u as=13.936p ps=54.12u w=53.6u l=0.7u
X838 a_41764_160995# a_41764_160995# VSS VSS nfet_06v0 ad=13.936p pd=54.12u as=23.584p ps=0.10808m w=53.6u l=0.7u
X839 a_41764_160995# a_41764_160995# VSS VSS nfet_06v0 ad=13.936p pd=54.12u as=13.936p ps=54.12u w=53.6u l=0.7u
X840 ESD_RAIL ESD_RAIL a_41764_148611# VSS nfet_06v0 ad=13.936p pd=54.12u as=23.584p ps=0.10808m w=53.6u l=0.7u
X841 ESD_RAIL ESD_RAIL a_41764_148611# VSS nfet_06v0 ad=13.936p pd=54.12u as=23.584p ps=0.10808m w=53.6u l=0.7u
X842 ESD_RAIL ESD_RAIL a_41764_148611# VSS nfet_06v0 ad=13.936p pd=54.12u as=13.936p ps=54.12u w=53.6u l=0.7u
X843 a_41764_160995# a_41764_148611# a_41764_148611# VSS nfet_06v0 ad=23.584p pd=0.10808m as=13.936p ps=54.12u w=53.6u l=0.7u
D21 VSS ESD_RAIL diode_nd2ps_06v0 pj=82u area=40p
X844 VSS a_41764_160995# a_41764_160995# VSS nfet_06v0 ad=13.936p pd=54.12u as=13.936p ps=54.12u w=53.6u l=0.7u
X845 a_41764_148611# a_41764_148611# a_41764_160995# VSS nfet_06v0 ad=13.936p pd=54.12u as=13.936p ps=54.12u w=53.6u l=0.7u
X846 VSS a_41764_160995# a_41764_160995# VSS nfet_06v0 ad=23.584p pd=0.10808m as=13.936p ps=54.12u w=53.6u l=0.7u
X847 a_41764_148611# a_41764_148611# a_41764_160995# VSS nfet_06v0 ad=13.936p pd=54.12u as=13.936p ps=54.12u w=53.6u l=0.7u
X848 a_41764_148611# ESD_RAIL ESD_RAIL VSS nfet_06v0 ad=13.936p pd=54.12u as=13.936p ps=54.12u w=53.6u l=0.7u
X849 a_41764_148611# ESD_RAIL ESD_RAIL VSS nfet_06v0 ad=23.584p pd=0.10808m as=13.936p ps=54.12u w=53.6u l=0.7u
X850 DIV_LOW_N DIV_ENABLE VSS VSS nfet_03v3 ad=8.8p pd=40.88u as=8.8p ps=40.88u w=20u l=0.28u
X851 VSS a_42245_90628# ESD_RAIL VSS nfet_06v0 ad=13p pd=50.52u as=13p ps=50.52u w=50u l=0.7u
X852 VSS a_42245_90628# ESD_RAIL VSS nfet_06v0 ad=13p pd=50.52u as=13p ps=50.52u w=50u l=0.7u
X853 VDD FS_N_GATE FS_N_WELL FS_N_WELL pfet_03v3 ad=6.16p pd=28.88u as=6.16p ps=28.88u w=14u l=0.28u
X854 a_41764_148611# a_41764_148611# a_41764_160995# VSS nfet_06v0 ad=13.936p pd=54.12u as=23.584p ps=0.10808m w=53.6u l=0.7u
X855 ESD_RAIL ESD_RAIL a_41764_148611# VSS nfet_06v0 ad=13.936p pd=54.12u as=13.936p ps=54.12u w=53.6u l=0.7u
X856 VSS a_42245_90628# ESD_RAIL VSS nfet_06v0 ad=13p pd=50.52u as=13p ps=50.52u w=50u l=0.7u
X857 a_42245_90628# VSS VSS ppolyf_u_1k_6p0 r_width=1u r_length=99.24u
X858 VSS a_42245_90628# ESD_RAIL VSS nfet_06v0 ad=13p pd=50.52u as=13p ps=50.52u w=50u l=0.7u
X859 ESD_RAIL a_42245_90628# VSS VSS nfet_06v0 ad=13p pd=50.52u as=13p ps=50.52u w=50u l=0.7u
X860 a_41764_160995# a_41764_148611# a_41764_148611# VSS nfet_06v0 ad=13.936p pd=54.12u as=13.936p ps=54.12u w=53.6u l=0.7u
X861 VSS a_41764_160995# a_41764_160995# VSS nfet_06v0 ad=13.936p pd=54.12u as=13.936p ps=54.12u w=53.6u l=0.7u
X862 HS_P_7 HS_P PAD_P VSS nfet_06v0 ad=8.8p pd=40.88u as=8.8p ps=40.88u w=20u l=0.7u
X863 TERM_GATE_P_BLEED_0 TERM_GATE_P_BLEED_1 VSS ppolyf_u_1k r_width=1u r_length=12.5u
X864 ESD_RAIL ESD_RAIL a_41764_148611# VSS nfet_06v0 ad=13.936p pd=54.12u as=13.936p ps=54.12u w=53.6u l=0.7u
X865 a_41764_148611# ESD_RAIL ESD_RAIL VSS nfet_06v0 ad=13.936p pd=54.12u as=13.936p ps=54.12u w=53.6u l=0.7u
X866 VSS a_41764_160995# a_41764_160995# VSS nfet_06v0 ad=13.936p pd=54.12u as=13.936p ps=54.12u w=53.6u l=0.7u
X867 a_41764_148611# a_41764_148611# a_41764_160995# VSS nfet_06v0 ad=13.936p pd=54.12u as=13.936p ps=54.12u w=53.6u l=0.7u
X868 a_41764_148611# a_41764_148611# a_41764_160995# VSS nfet_06v0 ad=13.936p pd=54.12u as=13.936p ps=54.12u w=53.6u l=0.7u
X869 a_41764_160995# a_41764_160995# VSS VSS nfet_06v0 ad=13.936p pd=54.12u as=13.936p ps=54.12u w=53.6u l=0.7u
X870 a_41764_160995# a_41764_160995# VSS VSS nfet_06v0 ad=13.936p pd=54.12u as=13.936p ps=54.12u w=53.6u l=0.7u
X871 a_41764_160995# a_41764_148611# a_41764_148611# VSS nfet_06v0 ad=13.936p pd=54.12u as=13.936p ps=54.12u w=53.6u l=0.7u
X872 ESD_RAIL a_42245_90628# VSS VSS nfet_06v0 ad=22p pd=0.10088m as=13p ps=50.52u w=50u l=0.7u
X873 a_41005_133505# a_53878_133225# ESD_RAIL ppolyf_u r_width=0.8u r_length=63.855u
X874 ESD_RAIL ESD_RAIL a_41764_148611# VSS nfet_06v0 ad=13.936p pd=54.12u as=13.936p ps=54.12u w=53.6u l=0.7u
X875 FS_P_BLEED_5 FS_P_BLEED_6 VSS ppolyf_u_1k r_width=1u r_length=12.5u
X876 PULLUP_P_OUT PULLUP_P_GATE PULLUP_P_WELL PULLUP_P_WELL pfet_03v3 ad=8.8p pd=40.88u as=8.8p ps=40.88u w=20u l=0.28u
X877 VDD FS_P_GATE FS_P_WELL FS_P_WELL pfet_03v3 ad=6.16p pd=28.88u as=6.16p ps=28.88u w=14u l=0.28u
X878 a_41764_160995# a_41764_160995# VSS VSS nfet_06v0 ad=13.936p pd=54.12u as=13.936p ps=54.12u w=53.6u l=0.7u
X879 DIV_P DIV_LOW_P VSS ppolyf_u_1k r_width=1u r_length=2u
X880 a_41764_148611# ESD_RAIL ESD_RAIL VSS nfet_06v0 ad=23.584p pd=0.10808m as=13.936p ps=54.12u w=53.6u l=0.7u
X881 TERM_N_R TERM_GATE_N TERM_VCM VSS nfet_03v3 ad=8.8p pd=40.88u as=8.8p ps=40.88u w=20u l=0.28u
X882 a_41764_160995# a_41764_160995# VSS VSS nfet_06v0 ad=13.936p pd=54.12u as=13.936p ps=54.12u w=53.6u l=0.7u
X883 a_41764_160995# a_41764_148611# a_41764_148611# VSS nfet_06v0 ad=13.936p pd=54.12u as=13.936p ps=54.12u w=53.6u l=0.7u
X884 HS_P_1 HS_P PAD_P VSS nfet_06v0 ad=8.8p pd=40.88u as=8.8p ps=40.88u w=20u l=0.7u
X885 a_41764_160995# a_41764_160995# VSS VSS nfet_06v0 ad=13.936p pd=54.12u as=13.936p ps=54.12u w=53.6u l=0.7u
X886 TERM_P_R TERM_GATE_P TERM_VCM VSS nfet_03v3 ad=8.8p pd=40.88u as=8.8p ps=40.88u w=20u l=0.28u
X887 a_41764_160995# a_41764_148611# a_41764_148611# VSS nfet_06v0 ad=13.936p pd=54.12u as=13.936p ps=54.12u w=53.6u l=0.7u
X888 HS_N_5 HS_PBIAS VDD VDD pfet_03v3 ad=8.8p pd=40.88u as=8.8p ps=40.88u w=20u l=1u
X889 VSS a_41764_160995# a_41764_160995# VSS nfet_06v0 ad=13.936p pd=54.12u as=13.936p ps=54.12u w=53.6u l=0.7u
X890 PAD_P TERM_P_R VSS ppolyf_u r_width=16u r_length=1.3u
X891 TERM_N_R TERM_GATE_N TERM_VCM VSS nfet_03v3 ad=8.8p pd=40.88u as=8.8p ps=40.88u w=20u l=0.28u
X892 HS_P_4 HS_P PAD_P VSS nfet_06v0 ad=8.8p pd=40.88u as=8.8p ps=40.88u w=20u l=0.7u
X893 a_41764_148611# a_41764_148611# a_41764_160995# VSS nfet_06v0 ad=13.936p pd=54.12u as=13.936p ps=54.12u w=53.6u l=0.7u
X894 a_41764_148611# ESD_RAIL ESD_RAIL VSS nfet_06v0 ad=13.936p pd=54.12u as=13.936p ps=54.12u w=53.6u l=0.7u
X895 VSS a_41764_160995# a_41764_160995# VSS nfet_06v0 ad=13.936p pd=54.12u as=13.936p ps=54.12u w=53.6u l=0.7u
X896 a_41764_148611# a_41764_148611# a_41764_160995# VSS nfet_06v0 ad=13.936p pd=54.12u as=13.936p ps=54.12u w=53.6u l=0.7u
X897 VSS a_42245_90628# ESD_RAIL VSS nfet_06v0 ad=13p pd=50.52u as=13p ps=50.52u w=50u l=0.7u
X898 FS_P_GATE VDD FS_P_WELL FS_P_WELL pfet_03v3 ad=1.76p pd=8.88u as=1.76p ps=8.88u w=4u l=0.28u
X899 a_41764_160995# a_41764_160995# VSS VSS nfet_06v0 ad=13.936p pd=54.12u as=13.936p ps=54.12u w=53.6u l=0.7u
X900 FS_N_BLEED_2 FS_N_BLEED_3 VSS ppolyf_u_1k r_width=1u r_length=12.5u
X901 ESD_RAIL ESD_RAIL a_41764_148611# VSS nfet_06v0 ad=13.936p pd=54.12u as=13.936p ps=54.12u w=53.6u l=0.7u
X902 ESD_RAIL ESD_RAIL a_41764_148611# VSS nfet_06v0 ad=13.936p pd=54.12u as=13.936p ps=54.12u w=53.6u l=0.7u
X903 FS_N_GATE FS_HIGH_N FS_N_WELL FS_N_WELL pfet_03v3 ad=1.76p pd=8.88u as=1.76p ps=8.88u w=4u l=0.28u
X904 DIV_N DIV_LOW_N VSS ppolyf_u_1k r_width=1u r_length=2u
X905 TERM_GATE_N TERM_GATE_N_BLEED_0 VSS ppolyf_u_1k r_width=1u r_length=12.5u
X906 VSS a_41764_160995# a_41764_160995# VSS nfet_06v0 ad=13.936p pd=54.12u as=13.936p ps=54.12u w=53.6u l=0.7u
X907 ESD_RAIL a_44789_117064# a_42245_90628# ESD_RAIL pfet_06v0 ad=1.3p pd=5.52u as=1.3p ps=5.52u w=5u l=0.7u
X908 PULLUP_N_WELL PULLUP_N_BLEED_0 VSS ppolyf_u_1k r_width=1u r_length=12.5u
X909 FS_P_BLEED_3 FS_P_BLEED_4 VSS ppolyf_u_1k r_width=1u r_length=12.5u
X910 a_41764_148611# a_41764_148611# a_41764_160995# VSS nfet_06v0 ad=13.936p pd=54.12u as=13.936p ps=54.12u w=53.6u l=0.7u
X911 a_41764_148611# ESD_RAIL ESD_RAIL VSS nfet_06v0 ad=13.936p pd=54.12u as=13.936p ps=54.12u w=53.6u l=0.7u
X912 ESD_RAIL a_42245_90628# VSS VSS nfet_06v0 ad=13p pd=50.52u as=13p ps=50.52u w=50u l=0.7u
X913 VSS a_41764_160995# a_41764_160995# VSS nfet_06v0 ad=23.584p pd=0.10808m as=13.936p ps=54.12u w=53.6u l=0.7u
X914 PULLUP_P_BLEED_2 PULLUP_P_BLEED_3 VSS ppolyf_u_1k r_width=1u r_length=12.5u
X915 PULLUP_P_OUT PULLUP_P_GATE PULLUP_P_WELL PULLUP_P_WELL pfet_03v3 ad=8.8p pd=40.88u as=8.8p ps=40.88u w=20u l=0.28u
X916 VDD FS_P_GATE FS_P_WELL FS_P_WELL pfet_03v3 ad=6.16p pd=28.88u as=6.16p ps=28.88u w=14u l=0.28u
X917 VSS a_41764_160995# a_41764_160995# VSS nfet_06v0 ad=13.936p pd=54.12u as=13.936p ps=54.12u w=53.6u l=0.7u
X918 ESD_RAIL a_53878_134345# ESD_RAIL ppolyf_u r_width=0.8u r_length=63.855u
X919 FS_N_BLEED_4 FS_N_BLEED_5 VSS ppolyf_u_1k r_width=1u r_length=12.5u
X920 ESD_RAIL ESD_RAIL a_41764_148611# VSS nfet_06v0 ad=13.936p pd=54.12u as=13.936p ps=54.12u w=53.6u l=0.7u
D22 VSS PAD_N diode_nd2ps_06v0 pj=51.8u area=22.5p
D23 PAD_P ESD_RAIL diode_pd2nw_06v0 pj=51.8u area=22.5p
X921 a_41764_160995# a_41764_148611# a_41764_148611# VSS nfet_06v0 ad=13.936p pd=54.12u as=13.936p ps=54.12u w=53.6u l=0.7u
X922 a_41764_160995# a_41764_148611# a_41764_148611# VSS nfet_06v0 ad=13.936p pd=54.12u as=13.936p ps=54.12u w=53.6u l=0.7u
X923 HS_P_13 HS_P PAD_P VSS nfet_06v0 ad=8.8p pd=40.88u as=8.8p ps=40.88u w=20u l=0.7u
X924 ESD_RAIL ESD_RAIL a_41764_148611# VSS nfet_06v0 ad=13.936p pd=54.12u as=13.936p ps=54.12u w=53.6u l=0.7u
X925 ESD_RAIL ESD_RAIL a_41764_148611# VSS nfet_06v0 ad=13.936p pd=54.12u as=13.936p ps=54.12u w=53.6u l=0.7u
X926 VSS a_41764_160995# a_41764_160995# VSS nfet_06v0 ad=13.936p pd=54.12u as=13.936p ps=54.12u w=53.6u l=0.7u
X927 a_41764_160995# a_41764_160995# VSS VSS nfet_06v0 ad=13.936p pd=54.12u as=23.584p ps=0.10808m w=53.6u l=0.7u
X928 ESD_RAIL ESD_RAIL a_41764_148611# VSS nfet_06v0 ad=13.936p pd=54.12u as=13.936p ps=54.12u w=53.6u l=0.7u
X929 a_41764_148611# a_41764_148611# a_41764_160995# VSS nfet_06v0 ad=13.936p pd=54.12u as=13.936p ps=54.12u w=53.6u l=0.7u
X930 VDD PULLUP_N_GATE PULLUP_N_WELL PULLUP_N_WELL pfet_03v3 ad=8.8p pd=40.88u as=8.8p ps=40.88u w=20u l=0.28u
X931 HS_N_3 HS_PBIAS VDD VDD pfet_03v3 ad=8.8p pd=40.88u as=8.8p ps=40.88u w=20u l=1u
X932 a_41764_148611# ESD_RAIL ESD_RAIL VSS nfet_06v0 ad=13.936p pd=54.12u as=13.936p ps=54.12u w=53.6u l=0.7u
X933 a_41764_160995# a_41764_160995# VSS VSS nfet_06v0 ad=13.936p pd=54.12u as=13.936p ps=54.12u w=53.6u l=0.7u
X934 ESD_RAIL ESD_RAIL a_41764_148611# VSS nfet_06v0 ad=13.936p pd=54.12u as=13.936p ps=54.12u w=53.6u l=0.7u
X935 a_41764_148611# a_41764_148611# a_41764_160995# VSS nfet_06v0 ad=13.936p pd=54.12u as=13.936p ps=54.12u w=53.6u l=0.7u
X936 VDD FS_P_GATE FS_P_WELL FS_P_WELL pfet_03v3 ad=6.16p pd=28.88u as=6.16p ps=28.88u w=14u l=0.28u
X937 a_41764_160995# a_41764_160995# VSS VSS nfet_06v0 ad=13.936p pd=54.12u as=13.936p ps=54.12u w=53.6u l=0.7u
X938 a_41764_160995# a_41764_148611# a_41764_148611# VSS nfet_06v0 ad=23.584p pd=0.10808m as=13.936p ps=54.12u w=53.6u l=0.7u
X939 VSS a_41764_160995# a_41764_160995# VSS nfet_06v0 ad=13.936p pd=54.12u as=13.936p ps=54.12u w=53.6u l=0.7u
X940 a_41764_148611# ESD_RAIL ESD_RAIL VSS nfet_06v0 ad=13.936p pd=54.12u as=13.936p ps=54.12u w=53.6u l=0.7u
X941 VSS a_42245_90628# ESD_RAIL VSS nfet_06v0 ad=13p pd=50.52u as=22p ps=0.10088m w=50u l=0.7u
X942 a_41764_160995# a_41764_148611# a_41764_148611# VSS nfet_06v0 ad=13.936p pd=54.12u as=13.936p ps=54.12u w=53.6u l=0.7u
X943 a_41764_160995# a_41764_148611# a_41764_148611# VSS nfet_06v0 ad=13.936p pd=54.12u as=13.936p ps=54.12u w=53.6u l=0.7u
X944 a_41764_148611# ESD_RAIL ESD_RAIL VSS nfet_06v0 ad=23.584p pd=0.10808m as=13.936p ps=54.12u w=53.6u l=0.7u
X945 VDD FS_P_GATE FS_P_WELL FS_P_WELL pfet_03v3 ad=6.16p pd=28.88u as=6.16p ps=28.88u w=14u l=0.28u
X946 a_41764_148611# a_41764_148611# a_41764_160995# VSS nfet_06v0 ad=13.936p pd=54.12u as=23.584p ps=0.10808m w=53.6u l=0.7u
X947 a_41764_148611# a_41764_148611# a_41764_160995# VSS nfet_06v0 ad=13.936p pd=54.12u as=13.936p ps=54.12u w=53.6u l=0.7u
X948 a_41764_148611# ESD_RAIL ESD_RAIL VSS nfet_06v0 ad=13.936p pd=54.12u as=13.936p ps=54.12u w=53.6u l=0.7u
X949 a_41764_148611# ESD_RAIL ESD_RAIL VSS nfet_06v0 ad=13.936p pd=54.12u as=13.936p ps=54.12u w=53.6u l=0.7u
X950 a_41764_160995# a_41764_160995# VSS VSS nfet_06v0 ad=13.936p pd=54.12u as=13.936p ps=54.12u w=53.6u l=0.7u
X951 VSS a_42245_90628# ESD_RAIL VSS nfet_06v0 ad=13p pd=50.52u as=13p ps=50.52u w=50u l=0.7u
X952 ESD_RAIL a_42245_90628# VSS VSS nfet_06v0 ad=13p pd=50.52u as=13p ps=50.52u w=50u l=0.7u
X953 HS_N_12 HS_N PAD_N VSS nfet_06v0 ad=8.8p pd=40.88u as=8.8p ps=40.88u w=20u l=0.7u
X954 a_41764_148611# ESD_RAIL ESD_RAIL VSS nfet_06v0 ad=13.936p pd=54.12u as=13.936p ps=54.12u w=53.6u l=0.7u
X955 ESD_RAIL a_42245_90628# VSS VSS nfet_06v0 ad=13p pd=50.52u as=13p ps=50.52u w=50u l=0.7u
D24 VSS PAD_P diode_nd2ps_06v0 pj=51.8u area=22.5p
X956 PAD_N BYPASS_ENABLE RX_N VSS nfet_06v0 ad=8.8p pd=40.88u as=8.8p ps=40.88u w=20u l=0.7u
X957 a_41764_160995# a_41764_148611# a_41764_148611# VSS nfet_06v0 ad=23.584p pd=0.10808m as=13.936p ps=54.12u w=53.6u l=0.7u
X958 a_41764_160995# a_41764_148611# a_41764_148611# VSS nfet_06v0 ad=13.936p pd=54.12u as=13.936p ps=54.12u w=53.6u l=0.7u
X959 ESD_RAIL a_42245_90628# VSS VSS nfet_06v0 ad=13p pd=50.52u as=13p ps=50.52u w=50u l=0.7u
X960 a_41764_148611# ESD_RAIL ESD_RAIL VSS nfet_06v0 ad=13.936p pd=54.12u as=13.936p ps=54.12u w=53.6u l=0.7u
X961 FS_N_OUT FS_N_GATE FS_N_WELL FS_N_WELL pfet_03v3 ad=6.16p pd=28.88u as=6.16p ps=28.88u w=14u l=0.28u
X962 VSS a_41764_160995# a_41764_160995# VSS nfet_06v0 ad=13.936p pd=54.12u as=13.936p ps=54.12u w=53.6u l=0.7u
X963 ESD_RAIL ESD_RAIL a_41764_148611# VSS nfet_06v0 ad=13.936p pd=54.12u as=13.936p ps=54.12u w=53.6u l=0.7u
X964 VSS a_42245_90628# ESD_RAIL VSS nfet_06v0 ad=13p pd=50.52u as=13p ps=50.52u w=50u l=0.7u
X965 VSS a_41764_160995# a_41764_160995# VSS nfet_06v0 ad=13.936p pd=54.12u as=13.936p ps=54.12u w=53.6u l=0.7u
X966 VSS a_41764_160995# a_41764_160995# VSS nfet_06v0 ad=13.936p pd=54.12u as=13.936p ps=54.12u w=53.6u l=0.7u
X967 a_41764_148611# ESD_RAIL ESD_RAIL VSS nfet_06v0 ad=13.936p pd=54.12u as=13.936p ps=54.12u w=53.6u l=0.7u
X968 FS_N_OUT FS_N_GATE FS_N_WELL FS_N_WELL pfet_03v3 ad=6.16p pd=28.88u as=6.16p ps=28.88u w=14u l=0.28u
X969 ESD_RAIL ESD_RAIL a_41764_148611# VSS nfet_06v0 ad=13.936p pd=54.12u as=13.936p ps=54.12u w=53.6u l=0.7u
X970 a_41764_160995# a_41764_160995# VSS VSS nfet_06v0 ad=13.936p pd=54.12u as=13.936p ps=54.12u w=53.6u l=0.7u
X971 HS_P_9 HS_P PAD_P VSS nfet_06v0 ad=8.8p pd=40.88u as=8.8p ps=40.88u w=20u l=0.7u
X972 VDD PULLUP_N_GATE PULLUP_N_WELL PULLUP_N_WELL pfet_03v3 ad=8.8p pd=40.88u as=8.8p ps=40.88u w=20u l=0.28u
X973 FS_N_OUT FS_N_GATE FS_N_WELL FS_N_WELL pfet_03v3 ad=6.16p pd=28.88u as=6.16p ps=28.88u w=14u l=0.28u
X974 VDD FS_P_GATE FS_P_WELL FS_P_WELL pfet_03v3 ad=6.16p pd=28.88u as=6.16p ps=28.88u w=14u l=0.28u
X975 ESD_RAIL ESD_RAIL a_41764_148611# VSS nfet_06v0 ad=13.936p pd=54.12u as=13.936p ps=54.12u w=53.6u l=0.7u
X976 a_41764_160995# a_41764_160995# VSS VSS nfet_06v0 ad=13.936p pd=54.12u as=13.936p ps=54.12u w=53.6u l=0.7u
X977 a_41764_160995# a_41764_148611# a_41764_148611# VSS nfet_06v0 ad=13.936p pd=54.12u as=13.936p ps=54.12u w=53.6u l=0.7u
X978 a_41764_160995# a_41764_148611# a_41764_148611# VSS nfet_06v0 ad=13.936p pd=54.12u as=13.936p ps=54.12u w=53.6u l=0.7u
X979 FS_N_OUT FS_N_GATE FS_N_WELL FS_N_WELL pfet_03v3 ad=6.16p pd=28.88u as=6.16p ps=28.88u w=14u l=0.28u
X980 VSS a_41764_160995# a_41764_160995# VSS nfet_06v0 ad=13.936p pd=54.12u as=13.936p ps=54.12u w=53.6u l=0.7u
X981 VSS a_41764_160995# a_41764_160995# VSS nfet_06v0 ad=13.936p pd=54.12u as=13.936p ps=54.12u w=53.6u l=0.7u
X982 a_41764_148611# a_41764_148611# a_41764_160995# VSS nfet_06v0 ad=13.936p pd=54.12u as=13.936p ps=54.12u w=53.6u l=0.7u
X983 HS_P_2 HS_PBIAS VDD VDD pfet_03v3 ad=8.8p pd=40.88u as=8.8p ps=40.88u w=20u l=1u
X984 a_41764_148611# a_41764_148611# a_41764_160995# VSS nfet_06v0 ad=13.936p pd=54.12u as=13.936p ps=54.12u w=53.6u l=0.7u
X985 a_41764_148611# ESD_RAIL ESD_RAIL VSS nfet_06v0 ad=13.936p pd=54.12u as=13.936p ps=54.12u w=53.6u l=0.7u
X986 a_41764_160995# a_41764_160995# VSS VSS nfet_06v0 ad=13.936p pd=54.12u as=13.936p ps=54.12u w=53.6u l=0.7u
X987 a_41764_160995# a_41764_160995# VSS VSS nfet_06v0 ad=13.936p pd=54.12u as=23.584p ps=0.10808m w=53.6u l=0.7u
X988 ESD_RAIL ESD_RAIL a_41764_148611# VSS nfet_06v0 ad=13.936p pd=54.12u as=13.936p ps=54.12u w=53.6u l=0.7u
X989 ESD_RAIL ESD_RAIL a_41764_148611# VSS nfet_06v0 ad=13.936p pd=54.12u as=13.936p ps=54.12u w=53.6u l=0.7u
X990 a_41764_160995# a_41764_160995# VSS VSS nfet_06v0 ad=13.936p pd=54.12u as=23.584p ps=0.10808m w=53.6u l=0.7u
X991 HS_P_8 HS_PBIAS VDD VDD pfet_03v3 ad=8.8p pd=40.88u as=8.8p ps=40.88u w=20u l=1u
X992 ESD_RAIL a_41005_131545# a_43813_117064# ESD_RAIL pfet_06v0 ad=1.3p pd=5.52u as=1.3p ps=5.52u w=5u l=0.7u
X993 VSS a_41764_160995# a_41764_160995# VSS nfet_06v0 ad=13.936p pd=54.12u as=13.936p ps=54.12u w=53.6u l=0.7u
X994 VSS a_41764_160995# a_41764_160995# VSS nfet_06v0 ad=13.936p pd=54.12u as=13.936p ps=54.12u w=53.6u l=0.7u
X995 a_41764_148611# a_41764_148611# a_41764_160995# VSS nfet_06v0 ad=13.936p pd=54.12u as=13.936p ps=54.12u w=53.6u l=0.7u
X996 VSS a_41764_160995# a_41764_160995# VSS nfet_06v0 ad=13.936p pd=54.12u as=13.936p ps=54.12u w=53.6u l=0.7u
X997 VDD FS_P_GATE FS_P_WELL FS_P_WELL pfet_03v3 ad=6.16p pd=28.88u as=6.16p ps=28.88u w=14u l=0.28u
X998 a_41764_148611# a_41764_148611# a_41764_160995# VSS nfet_06v0 ad=13.936p pd=54.12u as=13.936p ps=54.12u w=53.6u l=0.7u
X999 a_41764_148611# ESD_RAIL ESD_RAIL VSS nfet_06v0 ad=13.936p pd=54.12u as=13.936p ps=54.12u w=53.6u l=0.7u
X1000 VSS a_41764_160995# a_41764_160995# VSS nfet_06v0 ad=13.936p pd=54.12u as=13.936p ps=54.12u w=53.6u l=0.7u
X1001 a_41764_148611# a_41764_148611# a_41764_160995# VSS nfet_06v0 ad=13.936p pd=54.12u as=13.936p ps=54.12u w=53.6u l=0.7u
X1002 VDD FS_P_GATE FS_P_WELL FS_P_WELL pfet_03v3 ad=6.16p pd=28.88u as=6.16p ps=28.88u w=14u l=0.28u
X1003 FS_N_OUT FS_N_GATE FS_N_WELL FS_N_WELL pfet_03v3 ad=6.16p pd=28.88u as=6.16p ps=28.88u w=14u l=0.28u
X1004 HS_N_13 HS_PBIAS VDD VDD pfet_03v3 ad=8.8p pd=40.88u as=8.8p ps=40.88u w=20u l=1u
X1005 a_41764_160995# a_41764_160995# VSS VSS nfet_06v0 ad=13.936p pd=54.12u as=13.936p ps=54.12u w=53.6u l=0.7u
X1006 VDD FS_P_GATE FS_P_WELL FS_P_WELL pfet_03v3 ad=6.16p pd=28.88u as=6.16p ps=28.88u w=14u l=0.28u
X1007 a_41764_160995# a_41764_160995# VSS VSS nfet_06v0 ad=13.936p pd=54.12u as=13.936p ps=54.12u w=53.6u l=0.7u
X1008 a_41764_160995# a_41764_148611# a_41764_148611# VSS nfet_06v0 ad=13.936p pd=54.12u as=13.936p ps=54.12u w=53.6u l=0.7u
X1009 PAD_P DIV_P VSS ppolyf_u_1k r_width=1u r_length=2u
X1010 PULLDOWN_N_R PULLDOWN_N VSS VSS nfet_03v3 ad=3.52p pd=16.88u as=3.52p ps=16.88u w=8u l=0.28u
X1011 FS_P_OUT PAD_P VSS ppolyf_s r_width=2u r_length=3.5u
X1012 ESD_RAIL ESD_RAIL a_41764_148611# VSS nfet_06v0 ad=13.936p pd=54.12u as=13.936p ps=54.12u w=53.6u l=0.7u
X1013 a_41764_148611# ESD_RAIL ESD_RAIL VSS nfet_06v0 ad=13.936p pd=54.12u as=13.936p ps=54.12u w=53.6u l=0.7u
X1014 FS_N_OUT FS_N_GATE FS_N_WELL FS_N_WELL pfet_03v3 ad=6.16p pd=28.88u as=6.16p ps=28.88u w=14u l=0.28u
X1015 VSS a_41764_160995# a_41764_160995# VSS nfet_06v0 ad=13.936p pd=54.12u as=13.936p ps=54.12u w=53.6u l=0.7u
X1016 VDD FS_P_GATE FS_P_WELL FS_P_WELL pfet_03v3 ad=6.16p pd=28.88u as=6.16p ps=28.88u w=14u l=0.28u
X1017 a_41764_148611# a_41764_148611# a_41764_160995# VSS nfet_06v0 ad=13.936p pd=54.12u as=13.936p ps=54.12u w=53.6u l=0.7u
X1018 a_41764_160995# a_41764_148611# a_41764_148611# VSS nfet_06v0 ad=13.936p pd=54.12u as=13.936p ps=54.12u w=53.6u l=0.7u
D25 VSS PAD_N diode_nd2ps_06v0 pj=51.8u area=22.5p
X1019 a_41764_160995# a_41764_160995# VSS VSS nfet_06v0 ad=13.936p pd=54.12u as=23.584p ps=0.10808m w=53.6u l=0.7u
X1020 HS_P_0 HS_PBIAS VDD VDD pfet_03v3 ad=8.8p pd=40.88u as=8.8p ps=40.88u w=20u l=1u
X1021 a_41764_148611# ESD_RAIL ESD_RAIL VSS nfet_06v0 ad=13.936p pd=54.12u as=13.936p ps=54.12u w=53.6u l=0.7u
X1022 a_41764_160995# a_41764_160995# VSS VSS nfet_06v0 ad=13.936p pd=54.12u as=23.584p ps=0.10808m w=53.6u l=0.7u
X1023 a_41764_160995# a_41764_160995# VSS VSS nfet_06v0 ad=13.936p pd=54.12u as=13.936p ps=54.12u w=53.6u l=0.7u
X1024 TERM_GATE_N_BLEED_2 VSS VSS ppolyf_u_1k r_width=1u r_length=12.5u
X1025 PULLUP_P_OUT PULLUP_P_GATE PULLUP_P_WELL PULLUP_P_WELL pfet_03v3 ad=8.8p pd=40.88u as=8.8p ps=40.88u w=20u l=0.28u
X1026 VDD FS_P_GATE FS_P_WELL FS_P_WELL pfet_03v3 ad=6.16p pd=28.88u as=6.16p ps=28.88u w=14u l=0.28u
X1027 a_41764_160995# a_41764_148611# a_41764_148611# VSS nfet_06v0 ad=13.936p pd=54.12u as=13.936p ps=54.12u w=53.6u l=0.7u
X1028 ESD_RAIL ESD_RAIL a_41764_148611# VSS nfet_06v0 ad=13.936p pd=54.12u as=13.936p ps=54.12u w=53.6u l=0.7u
D26 VSS PAD_P diode_nd2ps_06v0 pj=51.8u area=22.5p
X1029 a_42245_90628# a_44789_117064# ESD_RAIL ESD_RAIL pfet_06v0 ad=1.3p pd=5.52u as=1.3p ps=5.52u w=5u l=0.7u
X1030 TERM_P_R TERM_GATE_P TERM_VCM VSS nfet_03v3 ad=8.8p pd=40.88u as=8.8p ps=40.88u w=20u l=0.28u
X1031 a_41764_160995# a_41764_148611# a_41764_148611# VSS nfet_06v0 ad=23.584p pd=0.10808m as=13.936p ps=54.12u w=53.6u l=0.7u
X1032 FS_N_OUT FS_N_GATE FS_N_WELL FS_N_WELL pfet_03v3 ad=6.16p pd=28.88u as=6.16p ps=28.88u w=14u l=0.28u
X1033 PULLUP_P_BLEED_5 PULLUP_P_BLEED_6 VSS ppolyf_u_1k r_width=1u r_length=12.5u
X1034 TERM_OR_N_B FS_LOW_N TERM_OR_N_NS VSS nfet_03v3 ad=0.88p pd=4.88u as=0.88p ps=4.88u w=2u l=0.28u
X1035 a_41764_160995# a_41764_148611# a_41764_148611# VSS nfet_06v0 ad=13.936p pd=54.12u as=13.936p ps=54.12u w=53.6u l=0.7u
X1036 VSS a_41764_160995# a_41764_160995# VSS nfet_06v0 ad=23.584p pd=0.10808m as=13.936p ps=54.12u w=53.6u l=0.7u
X1037 HS_P_2 HS_P PAD_P VSS nfet_06v0 ad=8.8p pd=40.88u as=8.8p ps=40.88u w=20u l=0.7u
X1038 VDD FS_P_GATE FS_P_WELL FS_P_WELL pfet_03v3 ad=6.16p pd=28.88u as=6.16p ps=28.88u w=14u l=0.28u
X1039 VSS a_42245_90628# ESD_RAIL VSS nfet_06v0 ad=13p pd=50.52u as=13p ps=50.52u w=50u l=0.7u
D27 VSS TERM_VCM diode_nd2ps_03v3 pj=2.4u area=0.36p
X1040 a_41764_148611# a_41764_148611# a_41764_160995# VSS nfet_06v0 ad=13.936p pd=54.12u as=23.584p ps=0.10808m w=53.6u l=0.7u
X1041 a_41764_148611# ESD_RAIL ESD_RAIL VSS nfet_06v0 ad=23.584p pd=0.10808m as=13.936p ps=54.12u w=53.6u l=0.7u
X1042 HS_N_7 HS_PBIAS VDD VDD pfet_03v3 ad=8.8p pd=40.88u as=8.8p ps=40.88u w=20u l=1u
X1043 a_41764_160995# a_41764_160995# VSS VSS nfet_06v0 ad=13.936p pd=54.12u as=13.936p ps=54.12u w=53.6u l=0.7u
X1044 a_41764_160995# a_41764_148611# a_41764_148611# VSS nfet_06v0 ad=13.936p pd=54.12u as=13.936p ps=54.12u w=53.6u l=0.7u
X1045 FS_N_OUT FS_N_GATE FS_N_WELL FS_N_WELL pfet_03v3 ad=6.16p pd=28.88u as=6.16p ps=28.88u w=14u l=0.28u
X1046 VDD FS_P_GATE FS_P_WELL FS_P_WELL pfet_03v3 ad=6.16p pd=28.88u as=6.16p ps=28.88u w=14u l=0.28u
X1047 ESD_RAIL a_42245_90628# VSS VSS nfet_06v0 ad=13p pd=50.52u as=13p ps=50.52u w=50u l=0.7u
X1048 VSS a_41764_160995# a_41764_160995# VSS nfet_06v0 ad=13.936p pd=54.12u as=13.936p ps=54.12u w=53.6u l=0.7u
X1049 ESD_RAIL a_42245_90628# VSS VSS nfet_06v0 ad=13p pd=50.52u as=13p ps=50.52u w=50u l=0.7u
X1050 a_41764_148611# ESD_RAIL ESD_RAIL VSS nfet_06v0 ad=13.936p pd=54.12u as=13.936p ps=54.12u w=53.6u l=0.7u
X1051 a_41764_148611# a_41764_148611# a_41764_160995# VSS nfet_06v0 ad=13.936p pd=54.12u as=13.936p ps=54.12u w=53.6u l=0.7u
X1052 a_41764_148611# ESD_RAIL ESD_RAIL VSS nfet_06v0 ad=13.936p pd=54.12u as=13.936p ps=54.12u w=53.6u l=0.7u
X1053 a_41764_148611# ESD_RAIL ESD_RAIL VSS nfet_06v0 ad=13.936p pd=54.12u as=13.936p ps=54.12u w=53.6u l=0.7u
X1054 a_41764_160995# a_41764_160995# VSS VSS nfet_06v0 ad=13.936p pd=54.12u as=23.584p ps=0.10808m w=53.6u l=0.7u
X1055 VSS a_41764_160995# a_41764_160995# VSS nfet_06v0 ad=13.936p pd=54.12u as=13.936p ps=54.12u w=53.6u l=0.7u
X1056 HS_N_9 HS_PBIAS VDD VDD pfet_03v3 ad=8.8p pd=40.88u as=8.8p ps=40.88u w=20u l=1u
X1057 a_41764_148611# a_41764_148611# a_41764_160995# VSS nfet_06v0 ad=13.936p pd=54.12u as=13.936p ps=54.12u w=53.6u l=0.7u
X1058 ESD_RAIL a_42245_90628# VSS VSS nfet_06v0 ad=13p pd=50.52u as=13p ps=50.52u w=50u l=0.7u
X1059 VSS a_42245_90628# ESD_RAIL VSS nfet_06v0 ad=13p pd=50.52u as=13p ps=50.52u w=50u l=0.7u
X1060 VSS a_41764_160995# a_41764_160995# VSS nfet_06v0 ad=13.936p pd=54.12u as=13.936p ps=54.12u w=53.6u l=0.7u
X1061 a_41764_160995# a_41764_160995# VSS VSS nfet_06v0 ad=13.936p pd=54.12u as=13.936p ps=54.12u w=53.6u l=0.7u
X1062 a_41764_160995# a_41764_148611# a_41764_148611# VSS nfet_06v0 ad=13.936p pd=54.12u as=13.936p ps=54.12u w=53.6u l=0.7u
X1063 ESD_RAIL a_42245_90628# VSS VSS nfet_06v0 ad=13p pd=50.52u as=13p ps=50.52u w=50u l=0.7u
X1064 a_42245_90628# a_44789_117064# ESD_RAIL ESD_RAIL pfet_06v0 ad=1.3p pd=5.52u as=1.3p ps=5.52u w=5u l=0.7u
X1065 TERM_OR_P_B TERM_ENABLE VSS VSS nfet_03v3 ad=0.88p pd=4.88u as=0.88p ps=4.88u w=2u l=0.28u
X1066 VSS a_41764_160995# a_41764_160995# VSS nfet_06v0 ad=13.936p pd=54.12u as=13.936p ps=54.12u w=53.6u l=0.7u
X1067 TERM_P_R DIFF_ENABLE TERM_N_R VSS nfet_03v3 ad=8.8p pd=40.88u as=8.8p ps=40.88u w=20u l=0.28u
X1068 a_41764_148611# a_41764_148611# a_41764_160995# VSS nfet_06v0 ad=13.936p pd=54.12u as=13.936p ps=54.12u w=53.6u l=0.7u
X1069 a_41764_148611# ESD_RAIL ESD_RAIL VSS nfet_06v0 ad=23.584p pd=0.10808m as=13.936p ps=54.12u w=53.6u l=0.7u
X1070 a_41764_160995# a_41764_160995# VSS VSS nfet_06v0 ad=13.936p pd=54.12u as=13.936p ps=54.12u w=53.6u l=0.7u
X1071 TERM_OR_P_NS VCM_LOW_OK VSS VSS nfet_03v3 ad=1.76p pd=8.88u as=1.76p ps=8.88u w=4u l=0.28u
X1072 ESD_RAIL ESD_RAIL a_41764_148611# VSS nfet_06v0 ad=13.936p pd=54.12u as=13.936p ps=54.12u w=53.6u l=0.7u
X1073 FS_N_OUT FS_N_GATE FS_N_WELL FS_N_WELL pfet_03v3 ad=6.16p pd=28.88u as=6.16p ps=28.88u w=14u l=0.28u
X1074 TERM_GATE_P_BLEED_1 TERM_GATE_P_BLEED_2 VSS ppolyf_u_1k r_width=1u r_length=12.5u
X1075 a_41764_160995# a_41764_160995# VSS VSS nfet_06v0 ad=13.936p pd=54.12u as=13.936p ps=54.12u w=53.6u l=0.7u
X1076 a_41764_160995# a_41764_160995# VSS VSS nfet_06v0 ad=13.936p pd=54.12u as=13.936p ps=54.12u w=53.6u l=0.7u
X1077 a_41764_160995# a_41764_148611# a_41764_148611# VSS nfet_06v0 ad=13.936p pd=54.12u as=13.936p ps=54.12u w=53.6u l=0.7u
X1078 a_41764_160995# a_41764_148611# a_41764_148611# VSS nfet_06v0 ad=13.936p pd=54.12u as=13.936p ps=54.12u w=53.6u l=0.7u
X1079 a_42245_90628# a_44789_117064# ESD_RAIL ESD_RAIL pfet_06v0 ad=1.3p pd=5.52u as=1.3p ps=5.52u w=5u l=0.7u
X1080 HS_N_11 HS_N PAD_N VSS nfet_06v0 ad=8.8p pd=40.88u as=8.8p ps=40.88u w=20u l=0.7u
X1081 ESD_RAIL ESD_RAIL a_41764_148611# VSS nfet_06v0 ad=13.936p pd=54.12u as=13.936p ps=54.12u w=53.6u l=0.7u
X1082 a_41764_160995# a_41764_160995# VSS VSS nfet_06v0 ad=13.936p pd=54.12u as=13.936p ps=54.12u w=53.6u l=0.7u
X1083 a_41764_160995# a_41764_148611# a_41764_148611# VSS nfet_06v0 ad=13.936p pd=54.12u as=13.936p ps=54.12u w=53.6u l=0.7u
X1084 VSS a_41764_160995# a_41764_160995# VSS nfet_06v0 ad=13.936p pd=54.12u as=13.936p ps=54.12u w=53.6u l=0.7u
X1085 a_41764_148611# ESD_RAIL ESD_RAIL VSS nfet_06v0 ad=13.936p pd=54.12u as=13.936p ps=54.12u w=53.6u l=0.7u
X1086 HS_N_0 HS_N PAD_N VSS nfet_06v0 ad=8.8p pd=40.88u as=8.8p ps=40.88u w=20u l=0.7u
X1087 VDD FS_P_GATE FS_P_WELL FS_P_WELL pfet_03v3 ad=6.16p pd=28.88u as=6.16p ps=28.88u w=14u l=0.28u
X1088 a_41764_160995# a_41764_160995# VSS VSS nfet_06v0 ad=13.936p pd=54.12u as=23.584p ps=0.10808m w=53.6u l=0.7u
X1089 a_41764_148611# ESD_RAIL ESD_RAIL VSS nfet_06v0 ad=13.936p pd=54.12u as=13.936p ps=54.12u w=53.6u l=0.7u
X1090 ESD_RAIL a_44789_117064# a_42245_90628# ESD_RAIL pfet_06v0 ad=1.3p pd=5.52u as=1.3p ps=5.52u w=5u l=0.7u
X1091 PAD_N BYPASS_ENABLE RX_N VSS nfet_06v0 ad=8.8p pd=40.88u as=8.8p ps=40.88u w=20u l=0.7u
X1092 a_41764_148611# a_41764_148611# a_41764_160995# VSS nfet_06v0 ad=13.936p pd=54.12u as=13.936p ps=54.12u w=53.6u l=0.7u
X1093 PAD_N BYPASS_ENABLE RX_N VSS nfet_06v0 ad=8.8p pd=40.88u as=8.8p ps=40.88u w=20u l=0.7u
X1094 a_41005_132385# a_53878_132105# ESD_RAIL ppolyf_u r_width=0.8u r_length=63.855u
X1095 a_41764_160995# a_41764_160995# VSS VSS nfet_06v0 ad=13.936p pd=54.12u as=13.936p ps=54.12u w=53.6u l=0.7u
X1096 ESD_RAIL ESD_RAIL a_41764_148611# VSS nfet_06v0 ad=13.936p pd=54.12u as=13.936p ps=54.12u w=53.6u l=0.7u
X1097 PULLUP_N_BLEED_2 PULLUP_N_BLEED_3 VSS ppolyf_u_1k r_width=1u r_length=12.5u
X1098 a_41764_148611# a_41764_148611# a_41764_160995# VSS nfet_06v0 ad=13.936p pd=54.12u as=13.936p ps=54.12u w=53.6u l=0.7u
X1099 ESD_RAIL ESD_RAIL a_41764_148611# VSS nfet_06v0 ad=13.936p pd=54.12u as=13.936p ps=54.12u w=53.6u l=0.7u
X1100 a_41764_160995# a_41764_160995# VSS VSS nfet_06v0 ad=13.936p pd=54.12u as=13.936p ps=54.12u w=53.6u l=0.7u
X1101 ESD_RAIL ESD_RAIL a_41764_148611# VSS nfet_06v0 ad=13.936p pd=54.12u as=13.936p ps=54.12u w=53.6u l=0.7u
C0 PULLUP_P_BLEED_4 HS_N_12 0.05263f
C1 TERM_GATE_N_BLEED_0 DIV_N 0.10151f
C2 HS_N_11 TERM_GATE_P 0.10852f
C3 RX_N DIV_N 1.36638f
C4 HS_P_0 HS_N_2 0.03722f
C5 a_43813_117064# a_41005_131545# 2.2693f
C6 PULLUP_P_GATE HS_N_6 0.08451f
C7 HS_P_4 HS_P_9 0.042f
C8 HS_N_13 HS_P_6 0.05888f
C9 FS_P_BLEED_4 HS_N_2 0.06178f
C10 FS_N_BLEED_4 FS_HIGH_P 0.09418f
C11 FS_N_BLEED_3 FS_N_BLEED_1 0.10633f
C12 HS_N_5 HS_N_2 0.00106f
C13 FS_P_BLEED_1 FS_HIGH_P 0.16649f
C14 PULLUP_P_GATE DIV_N 0.00178f
C15 PULLDOWN_P FS_N_BLEED_4 0.04811f
C16 HS_P_11 HS_P_1 0.05935f
C17 DIV_LOW_N PULLUP_P 0.10124f
C18 HS_N_4 HS_N_12 0
C19 DIV_ENABLE PULLUP_N_WELL 0.06147f
C20 HS_N_1 DIV_N 0.03462f
C21 TERM_GATE_N_BLEED_0 VDD 0.45815f
C22 TERM_ENABLE DIFF_ENABLE 0.17128f
C23 PULLUP_P_BLEED_2 PULLUP_N_OUT 0
C24 PULLDOWN_P_R FS_HIGH_P 0.04377f
C25 HS_P_0 HS_P_1 36.4065f
C26 FS_N_CONTROL_S HS_PBIAS 0.09439f
C27 DIV_N FS_P_BLEED_2 0
C28 FS_N_BLEED_2 PULLUP_P 0.10124f
C29 HS_P_8 TERM_GATE_P 0.15508f
C30 FS_N_WELL FS_HIGH_P 1.71197f
C31 PULLUP_P_GATE VDD 13.1722f
C32 HS_PBIAS FS_LOW_N 0.39667f
C33 PULLDOWN_P_R PULLDOWN_P 2.2366f
C34 PULLDOWN_P FS_N_WELL 2.59822f
C35 HS_P_11 HS_PBIAS 9.38284f
C36 PULLDOWN_N_R FS_HIGH_P 0.04377f
C37 HS_P_1 HS_N_5 0.03097f
C38 HS_N_1 VDD 4.91737f
C39 PULLUP_N_WELL PULLUP_N_BLEED_6 0.00637f
C40 FS_N_OUT VCM_LOW_OK 0.1125f
C41 FS_P_BLEED_0 TERM_N_R 0.11444f
C42 PULLDOWN_P PULLDOWN_N_R 88.8288f
C43 HS_N_2 FS_P_WELL 1.96621f
C44 FS_P_BLEED_5 FS_P_BLEED_6 5.16949f
C45 DIV_ENABLE FS_HIGH_N 3.66887f
C46 RX_P BYPASS_ENABLE 4.97887f
C47 HS_PBIAS HS_P_0 0.94883f
C48 FS_P_BLEED_4 HS_PBIAS 0.09926f
C49 HS_P_11 HS_P_5 0.03881f
C50 HS_PBIAS HS_N_5 4.87448f
C51 FS_P_GATE VCM_LOW_OK 1.23568f
C52 a_41005_131825# a_41005_132385# 0.0346f
C53 PULLUP_P_CONTROL_S PULLUP_P_GATE 1.18123f
C54 FS_P_BLEED_0 HS_P 0.06178f
C55 PULLUP_P_CONTROL_S HS_N_1 0.05002f
C56 PULLUP_N_GATE FS_LOW_N 0.17511f
C57 PULLUP_P_BLEED_4 VCM_LOW_OK 0
C58 HS_P_0 HS_P_5 0.00297f
C59 PAD_P HS_N_2 1.25659f
C60 FS_HIGH_N PULLUP_N_BLEED_6 0.15562f
C61 TERM_ENABLE FS_P_BLEED_6 0.08457f
C62 HS_N_8 PULLUP_P_WELL 0.13083f
C63 HS_N_5 HS_P_5 0.10295f
C64 PULLUP_P_BLEED_2 TERM_VCM 0.08967f
C65 DIV_N FS_N_OUT 0.07775f
C66 HS_N_9 FS_P_BLEED_6 0.06178f
C67 HS_N_4 VCM_LOW_OK 0.05893f
C68 HS_N DIV_LOW_P 0.06611f
C69 FS_P_GATE HS_N_6 1.04254f
C70 BYPASS_ENABLE FS_HIGH_P 0
C71 HS_N_8 HS_P_2 0.02404f
C72 HS_PBIAS FS_P_WELL 3.47125f
C73 FS_N_GATE HS_N_11 0.00893f
C74 PULLUP_N_BLEED_0 HS_P 0.07928f
C75 PAD_P HS_P_1 1.23389f
C76 HS_N_2 PULLUP_P_OUT 0.03489f
C77 HS_N FS_N_BLEED_4 0.06151f
C78 PULLDOWN_N PULLUP_N_BLEED_6 0
C79 PULLUP_P_BLEED_4 HS_N_6 0.0525f
C80 HS_N FS_P_BLEED_1 0.04405f
C81 FS_P_GATE DIV_N 0.09711f
C82 FS_N_OUT VDD 11.0129f
C83 TERM_OR_P_B HS_N_1 0.07438f
C84 PULLUP_P_BLEED_5 HS_N_11 0.02434f
C85 HS_P_10 TERM_P_R 0.14229f
C86 PULLUP_P_BLEED_3 HS_N_13 0.03489f
C87 PULLUP_P_BLEED_4 DIV_N 0
C88 HS_N_8 HS_N_3 0.03258f
C89 DIV_ENABLE DIV_LOW_N 9.85993f
C90 HS_N_2 HS_P_12 0.06578f
C91 FS_P_OUT PULLUP_N_OUT 0.573f
C92 HS_N PULLDOWN_P_R 0.04388f
C93 PULLUP_N_OUT TERM_P_R 0.26239f
C94 HS_N_0 HS_N_8 0.04157f
C95 HS_N_4 HS_N_6 0.05831f
C96 HS_N FS_N_WELL 4.96692f
C97 FS_P_GATE VDD 26.6621f
C98 PULLUP_P_WELL HS_N_7 0.12519f
C99 PAD_N HS_P_2 2.43754f
C100 HS_N_4 DIV_N 0.03462f
C101 PULLUP_P_BLEED_0 VDD 0.05459f
C102 HS_N PULLDOWN_N_R 0.12564f
C103 TERM_OR_N_NS TERM_N_R 0.04867f
C104 TERM_N_R HS_P 0.08926f
C105 PULLUP_P_CONTROL_S FS_N_OUT 0.05082f
C106 TERM_GATE_N_BLEED_1 TERM_GATE_N 0.42775f
C107 a_41005_132945# a_41005_132385# 0.0346f
C108 PAD_P HS_P_5 1.15443f
C109 HS_P_1 HS_P_12 0.05935f
C110 FS_N_BLEED_5 VDD 0.00257f
C111 TERM_OR_P_NS VCM_LOW_OK 2.92628f
C112 PULLUP_N_BLEED_5 DIFF_ENABLE 0
C113 HS_PBIAS PULLUP_P_OUT 0.55061f
C114 PULLUP_P_OUT TERM_GATE_P_BLEED_2 0.04242f
C115 PAD_N HS_N_3 1.66755f
C116 PULLUP_P PULLUP_P_WELL 0.15487f
C117 HS_N_4 VDD 6.4024f
C118 TERM_OR_N_NS HS_P 0.03425f
C119 PULLUP_P_CONTROL_S PULLUP_P_BLEED_0 0.00275f
C120 PAD_N HS_N_0 1.42664f
C121 HS_N_7 HS_N_3 0.06865f
C122 HS_PBIAS HS_P_12 4.10448f
C123 TERM_GATE_N_BLEED_0 HS_N_13 0.03489f
C124 TERM_GATE_N HS_N_2 0.04808f
C125 HS_N_8 HS_N_10 0.04444f
C126 HS_P_13 HS_P 0.71007f
C127 HS_N_0 HS_N_7 0.07359f
C128 FS_P_BLEED_3 HS_N_12 0.02888f
C129 FS_P_BLEED_5 HS_N_2 0.06178f
C130 PULLUP_N_OUT TERM_OR_N_B 0.09609f
C131 TERM_VCM TERM_P_R 0.19926p
C132 FS_P_OUT TERM_VCM 0.38638f
C133 TERM_OR_P_NS HS_N_6 0.00351f
C134 PULLUP_P_GATE HS_N_13 0.08296f
C135 PULLUP_P_CONTROL_S HS_N_4 0.04808f
C136 TERM_OR_P_B FS_N_OUT 0.05082f
C137 HS_P_5 HS_P_12 0.03887f
C138 HS_P_4 TERM_N_R 0.05722f
C139 DIV_LOW_N HS_N_12 0.06178f
C140 HS_N_1 HS_N_13 0.04843f
C141 TERM_ENABLE TERM_GATE_N_BLEED_1 0.07928f
C142 HS_N BYPASS_ENABLE 0.01049f
C143 PULLUP_P HS_N_3 0.02404f
C144 PULLUP_P_BLEED_1 PULLUP_P 0.23767f
C145 HS_N_9 TERM_GATE_N_BLEED_1 0.0525f
C146 HS_N_0 PULLUP_P 0.07466f
C147 HS_P_10 TERM_GATE_P 0.17903f
C148 HS_P_2 HS_P_7 0.06184f
C149 DIV_P HS_N_3 0.03388f
C150 FS_N_BLEED_3 PULLUP_P 0.10124f
C151 PAD_N HS_N_10 1.35483f
C152 HS_N HS_P_6 0.5265f
C153 TERM_P_R FS_LOW_P 0.15007f
C154 FS_P_OUT FS_LOW_P 0.53029f
C155 PULLUP_N_OUT TERM_GATE_P 0.37427f
C156 HS_P_4 HS_P 1.7567f
C157 TERM_GATE_N_BLEED_2 TERM_N_R 0.12212f
C158 TERM_ENABLE HS_N_2 0.04808f
C159 PULLDOWN_N_R DIFF_ENABLE 0.23599f
C160 HS_N_0 DIV_P 0.03388f
C161 HS_N_7 HS_N_10 0.03027f
C162 HS_N_8 TERM_OR_N_S 0.03108f
C163 HS_PBIAS TERM_GATE_N 0.13841f
C164 TERM_OR_P_NS VDD 0.04366f
C165 HS_N_8 HS_P_9 0.00649f
C166 PULLUP_P_BLEED_3 FS_HIGH_P 0.166f
C167 HS_N_9 HS_N_2 0
C168 HS_N_8 FS_P_CONTROL_S 0.03238f
C169 HS_P_4 HS_P_13 0.14463f
C170 PULLUP_N_WELL VDD 25.2292f
C171 FS_P_BLEED_5 HS_PBIAS 0.08856f
C172 TERM_OR_P_B HS_N_4 0.07211f
C173 TERM_GATE_N_BLEED_2 HS_P 0.10446f
C174 RX_N RX_P 20.1628f
C175 TERM_VCM TERM_OR_N_B 0.10825f
C176 HS_P_3 HS_P_2 34.3283f
C177 TERM_ENABLE HS_P_1 0.02404f
C178 PULLUP_P HS_N_10 0.02404f
C179 HS_P_1 HS_N_9 0.0312f
C180 PULLDOWN_P_R FS_P_BLEED_6 0.10124f
C181 FS_N_GATE FS_N_BLEED_6 2.79368f
C182 FS_HIGH_N VDD 0.2016f
C183 PAD_N HS_P_9 6.47937f
C184 DIV_ENABLE PULLUP_P_WELL 0.01343f
C185 TERM_ENABLE TERM_GATE_P_BLEED_2 0.07306f
C186 HS_P_3 HS_N_3 0.03733f
C187 TERM_ENABLE HS_PBIAS 0.73653f
C188 FS_P_BLEED_6 PULLDOWN_N_R 0.10124f
C189 HS_N_7 TERM_OR_N_S 0.02895f
C190 DIFF_ENABLE BYPASS_ENABLE 5.18795f
C191 TERM_VCM TERM_GATE_P 26.4481f
C192 HS_N_7 FS_P_CONTROL_S 0.03226f
C193 HS_PBIAS HS_N_9 1.96438f
C194 HS_N_0 HS_P_3 0.02686f
C195 TERM_GATE_N_BLEED_0 FS_HIGH_P 0.15807f
C196 FS_P_GATE HS_N_13 1.03609f
C197 PULLDOWN_P TERM_GATE_N_BLEED_0 0.04828f
C198 TERM_ENABLE HS_P_5 0.02404f
C199 FS_P_BLEED_3 HS_N_6 0.03529f
C200 PULLUP_P PULLUP_N 0.03743f
C201 TERM_OR_P_NS TERM_OR_P_B 3.40561f
C202 PULLUP_P_BLEED_4 HS_N_13 0.0525f
C203 PULLUP_P TERM_OR_N_S 0.13572f
C204 HS_N_9 HS_P_5 0.06578f
C205 HS_PBIAS PULLUP_P_BLEED_6 0.01633f
C206 PULLUP_P_GATE FS_HIGH_P 0.03189f
C207 FS_N_CONTROL_S TERM_P_R 0.11557f
C208 DIV_ENABLE HS_N_3 0.03089f
C209 HS_N_1 FS_HIGH_P 0.03577f
C210 PULLUP_P_GATE PULLDOWN_P 0.02056f
C211 TERM_ENABLE PULLUP_N_GATE 0.24055f
C212 DIV_LOW_N HS_N_6 0.06178f
C213 FS_LOW_P TERM_GATE_P 0.15357f
C214 HS_P_11 TERM_P_R 0.14852f
C215 DIV_LOW_N DIV_N 6.86692f
C216 FS_LOW_N TERM_P_R 0.03634f
C217 DIV_ENABLE HS_N_0 2.34864f
C218 HS_N_4 HS_N_13 0.14463f
C219 FS_P_BLEED_2 FS_HIGH_P 0.03577f
C220 FS_N_BLEED_1 HS_P 0.08856f
C221 FS_N_GATE PULLUP_N_OUT 1.02928f
C222 TERM_OR_P_NS TERM_OR_P_S 0.00736f
C223 HS_P_0 FS_P_OUT 0.09146f
C224 HS_N PULLUP_P_BLEED_3 0.04828f
C225 HS_P_3 HS_N_10 0.02545f
C226 HS_P_0 TERM_P_R 0.07626f
C227 HS_P_10 HS_N_11 0.1403f
C228 RX_P FS_N_OUT 0.01284f
C229 FS_P_OUT HS_N_5 0.43331f
C230 HS_P_9 HS_P_7 0.00206f
C231 PULLUP_N_OUT HS_N_11 0.01419f
C232 HS_N_5 TERM_P_R 0.05893f
C233 DIV_LOW_N VDD 0.25658f
C234 a_53878_134345# ESD_RAIL 0.5677f
C235 PULLUP_P_BLEED_5 PULLUP_N_OUT 0.09196f
C236 HS_N_8 FS_P_BLEED_0 0.06178f
C237 PULLUP_P_WELL HS_N_12 0.12571f
C238 a_53878_133225# ESD_RAIL 0.53916f
C239 DIV_ENABLE HS_N_10 0.03182f
C240 HS_P_8 HS_P_10 0.00926f
C241 FS_N_BLEED_2 VDD 0.01834f
C242 HS_P_8 PULLUP_N_OUT 0.0429f
C243 DIV_LOW_P HS_N_2 0
C244 FS_LOW_N TERM_OR_N_B 2.73977f
C245 FS_N_OUT FS_HIGH_P 0.17276f
C246 FS_P_WELL TERM_P_R 1.46056f
C247 HS_P_3 HS_P_9 0.04194f
C248 FS_P_OUT FS_P_WELL 0.18171p
C249 FS_N_GATE TERM_VCM 0.90423f
C250 PULLDOWN_P FS_N_OUT 0.57337f
C251 HS_N_3 HS_N_12 0.03984f
C252 HS_N TERM_GATE_N_BLEED_0 0.04828f
C253 FS_P_BLEED_1 HS_N_2 0.03472f
C254 TERM_GATE_N_BLEED_1 PULLDOWN_N_R 0.07928f
C255 HS_N_0 HS_N_12 0.04188f
C256 HS_N_7 FS_P_BLEED_0 0.06178f
C257 TERM_VCM HS_N_11 0.12019f
C258 FS_P_GATE FS_HIGH_P 5.63212f
C259 PULLUP_P_GATE HS_N 0.13616f
C260 HS_P_11 TERM_GATE_P 0.1736f
C261 PAD_P TERM_P_R 0.63614f
C262 HS_N HS_N_1 4.22798f
C263 PULLDOWN_P_R HS_N_2 0.02404f
C264 PULLUP_P_BLEED_4 FS_HIGH_P 0.03577f
C265 PAD_P FS_P_OUT 5.92309f
C266 FS_N_GATE FS_LOW_P 0.45819f
C267 HS_N_2 PULLDOWN_N_R 0.02404f
C268 HS_N FS_P_BLEED_2 0.01113f
C269 FS_N_BLEED_5 FS_HIGH_P 0.01355f
C270 HS_N_8 TERM_N_R 0.05914f
C271 HS_P_0 TERM_GATE_P 0.25837f
C272 FS_N_BLEED_0 VDD 0.04218f
C273 PULLUP_P_WELL VCM_LOW_OK 0.26131f
C274 HS_N_4 FS_HIGH_P 0.02404f
C275 DIV_LOW_P HS_PBIAS 0
C276 HS_N_11 FS_LOW_P 0.08505f
C277 HS_N_4 PULLDOWN_P 0.05303f
C278 HS_N_5 TERM_GATE_P 0.11502f
C279 HS_P_8 TERM_VCM 0.09675f
C280 HS_N_12 HS_N_10 0.07075f
C281 PULLUP_N PULLUP_N_BLEED_6 0.17333f
C282 PULLUP_N_BLEED_5 PULLUP_N_GATE 0.24191f
C283 PULLUP_P_OUT TERM_P_R 0.25969f
C284 PULLDOWN_P_R HS_P_1 0.08595f
C285 FS_P_OUT PULLUP_P_OUT 0.56159f
C286 HS_P_2 VCM_LOW_OK 0.03489f
C287 FS_P_BLEED_1 HS_PBIAS 0.04811f
C288 TERM_GATE_P_BLEED_0 HS_P_2 0.02483f
C289 HS_PBIAS FS_N_BLEED_4 0.04811f
C290 HS_N_8 TERM_OR_N_NS 0.03425f
C291 HS_N_8 HS_P 0.55444f
C292 TERM_N_R TERM_GATE_P_BLEED_1 0.23767f
C293 HS_P_1 PULLDOWN_N_R 0.06544f
C294 FS_P_OUT HS_P_12 0.10923f
C295 TERM_ENABLE PULLUP_P_BLEED_2 0.11229f
C296 DIV_LOW_P HS_P_5 0.00305f
C297 HS_P_12 TERM_P_R 0.11066f
C298 PULLUP_N_BLEED_1 PULLDOWN_N_R 0.07928f
C299 a_41764_148611# a_41764_160995# 1.23933p
C300 HS_N_8 HS_P_13 0.04828f
C301 PULLDOWN_P_R HS_PBIAS 0.50594f
C302 PULLUP_P_BLEED_1 VCM_LOW_OK 0.01462f
C303 HS_PBIAS FS_N_WELL 3.33611f
C304 PAD_N TERM_N_R 0.56726f
C305 HS_P_8 FS_LOW_P 0.04566f
C306 HS_N_3 VCM_LOW_OK 0.05893f
C307 PULLUP_P_WELL HS_N_6 0.12108f
C308 HS_N_0 VCM_LOW_OK 0.05893f
C309 HS_N_7 TERM_N_R 0.11615f
C310 PULLUP_P_WELL DIV_N 0.08038f
C311 HS_PBIAS PULLDOWN_N_R 0.82033f
C312 HS_P_2 HS_N_6 0.03089f
C313 FS_N_BLEED_4 PULLUP_N_GATE 0.00498f
C314 HS_N FS_N_OUT 1.15664f
C315 PULLDOWN_P_R HS_P_5 0.02404f
C316 PAD_N HS_P 1.82419f
C317 HS_N_12 TERM_OR_N_S 0.02482f
C318 FS_P_BLEED_3 HS_N_13 0.02846f
C319 HS_P_5 PULLDOWN_N_R 0.02411f
C320 TERM_OR_N_NS HS_N_7 0.03425f
C321 PULLUP_P_WELL VDD 30.3758f
C322 HS_N_12 FS_P_CONTROL_S 0.03226f
C323 HS_N_7 HS_P 0.33704f
C324 HS_N_2 HS_P_6 0.05876f
C325 PAD_N HS_P_13 0.16938f
C326 PULLUP_P TERM_N_R 0.34532f
C327 HS_N_8 HS_P_4 0.02404f
C328 DIV_LOW_N HS_N_13 0.06178f
C329 HS_N FS_P_GATE 2.29474f
C330 HS_N_6 HS_N_3 0.04183f
C331 FS_N_CONTROL_S FS_N_GATE 0.98908f
C332 TERM_GATE_N TERM_P_R 0.1818f
C333 PULLUP_N_WELL FS_HIGH_P 0.30751f
C334 HS_N_3 DIV_N 0.03505f
C335 PULLUP_N_GATE PULLDOWN_N_R 0.15922f
C336 HS_N_0 HS_N_6 0.04157f
C337 HS_P_2 VDD 5.70329f
C338 HS_N PULLUP_P_BLEED_4 0.10264f
C339 HS_N_7 HS_P_13 0.02404f
C340 PULLDOWN_P PULLUP_N_WELL 0.47103f
C341 HS_N_10 VCM_LOW_OK 0.05893f
C342 HS_N_0 DIV_N 0.03952f
C343 FS_N_GATE FS_LOW_N 0.75021f
C344 HS_N FS_N_BLEED_5 0.02443f
C345 PULLUP_P_CONTROL_S PULLUP_P_WELL 0.02696f
C346 PULLUP_P TERM_OR_N_NS 0.05397f
C347 PULLUP_P HS_P 0.02404f
C348 HS_P_1 HS_P_6 0.06271f
C349 HS_P_11 HS_N_11 0.06806f
C350 TERM_GATE_N_BLEED_2 HS_N_8 0.04243f
C351 PULLUP_P_BLEED_5 FS_LOW_N 0.02437f
C352 HS_N HS_N_4 1.43714f
C353 FS_LOW_N HS_N_11 0.08441f
C354 HS_N_3 VDD 5.65374f
C355 PULLUP_P_BLEED_1 VDD 0.07323f
C356 PULLUP_P_OUT TERM_GATE_P 0.40537f
C357 FS_HIGH_N FS_HIGH_P 29.9593f
C358 DIV_P HS_P 0.08005f
C359 PAD_N HS_P_4 0.27735f
C360 HS_N_0 VDD 4.91768f
C361 PULLDOWN_P FS_HIGH_N 0.03743f
C362 PULLUP_P_GATE FS_P_BLEED_6 0.023f
C363 HS_P_0 HS_N_11 0.04389f
C364 HS_P_12 TERM_GATE_P 0.16452f
C365 FS_N_BLEED_3 VDD 0.5567f
C366 HS_N_1 FS_P_BLEED_6 0.06178f
C367 FS_P_BLEED_4 HS_N_11 0.06178f
C368 HS_PBIAS HS_P_6 2.09103f
C369 HS_N_5 HS_N_11 0
C370 HS_N_6 HS_N_10 0
C371 m2_42279_124800# a_41005_132385# 0
C372 TERM_ENABLE TERM_P_R 0.46656f
C373 PULLUP_P_BLEED_5 HS_N_5 0.03089f
C374 HS_P_10 PULLUP_N_OUT 0.08961f
C375 TERM_ENABLE FS_P_OUT 0.53051f
C376 HS_P_7 HS_P 0.53303f
C377 FS_P_BLEED_6 FS_P_BLEED_2 0.06814f
C378 PULLUP_P_CONTROL_S HS_N_3 0.04808f
C379 HS_P_11 HS_P_8 0.00792f
C380 HS_N_10 DIV_N 0.03462f
C381 a_53878_132105# ESD_RAIL 0.53942f
C382 HS_N_9 TERM_P_R 0.0592f
C383 TERM_GATE_N TERM_OR_N_B 1.45686f
C384 HS_N_9 FS_P_OUT 0.43377f
C385 TERM_OR_N_S VCM_LOW_OK 2.91765f
C386 HS_P_9 VCM_LOW_OK 0.0458f
C387 PULLUP_P_CONTROL_S HS_N_0 0.05093f
C388 HS_P_7 HS_P_13 0.14204f
C389 HS_P_6 HS_P_5 32.3343f
C390 TERM_GATE_P_BLEED_0 HS_P_9 0.03888f
C391 DIV_ENABLE PULLUP_N_BLEED_0 0
C392 PULLDOWN_P PULLDOWN_N 2.04789f
C393 TERM_GATE_N_BLEED_2 HS_N_7 0.03702f
C394 HS_P_3 TERM_N_R 0.05037f
C395 TERM_OR_P_B HS_P_2 0.10307f
C396 HS_N_10 VDD 6.378f
C397 PULLUP_N PULLUP_N_BLEED_4 0.08101f
C398 TERM_ENABLE PULLUP_N_BLEED_3 0.01168f
C399 FS_P_WELL HS_N_11 2.03147f
C400 FS_N_BLEED_6 FS_LOW_P 0.05624f
C401 HS_P_3 HS_P 1.89056f
C402 PULLUP_N_GATE PULLUP_N_CONTROL_S 1.68347f
C403 TERM_GATE_N_BLEED_2 PULLUP_P 0.09196f
C404 PULLUP_N_BLEED_0 PULLUP_N_BLEED_6 0.00257f
C405 HS_N PULLUP_N_WELL 0.46804f
C406 HS_N_6 TERM_OR_N_S 0.02755f
C407 TERM_OR_P_B HS_N_3 0.07211f
C408 HS_N_12 FS_P_BLEED_0 0.06178f
C409 DIV_ENABLE TERM_N_R 0.09755f
C410 PULLUP_P_BLEED_3 HS_N_2 0.03489f
C411 DIV_LOW_N FS_HIGH_P 0.16534f
C412 TERM_ENABLE TERM_OR_N_B 1.2192f
C413 HS_P_3 HS_P_13 0.2651f
C414 HS_P_4 HS_P_7 0.06067f
C415 HS_N_6 FS_P_CONTROL_S 0.03226f
C416 DIV_LOW_N PULLDOWN_P 0.08856f
C417 PULLUP_P_CONTROL_S HS_N_10 0.04949f
C418 HS_P_10 TERM_VCM 0.13491f
C419 TERM_OR_P_B HS_N_0 0.07497f
C420 FS_N_OUT FS_P_BLEED_6 0.04877f
C421 HS_N_9 TERM_OR_N_B 0
C422 PAD_P HS_N_11 0.38848f
C423 PULLUP_N_OUT TERM_VCM 0.50835f
C424 DIV_ENABLE HS_P 0.03818f
C425 FS_N_BLEED_2 FS_HIGH_P 0
C426 PULLUP_N VDD 0.00338f
C427 FS_N_BLEED_2 PULLDOWN_P 0.08856f
C428 TERM_N_R PULLUP_N_BLEED_6 0.06125f
C429 TERM_GATE_N_BLEED_1 TERM_GATE_N_BLEED_0 7.21575f
C430 HS_N FS_HIGH_N 0.06561f
C431 HS_P_9 VDD 6.02581f
C432 FS_P_GATE FS_P_BLEED_6 6.82321f
C433 VDD TERM_OR_N_S 10.1707f
C434 HS_P_10 FS_LOW_P 0.05509f
C435 VDD FS_P_CONTROL_S 0.38621f
C436 a_41005_134065# m2_42279_124800# 0
C437 PULLUP_P_WELL HS_N_13 0.12105f
C438 TERM_ENABLE TERM_GATE_P 1.60491f
C439 HS_P_3 HS_P_4 33.6448f
C440 PULLUP_N_OUT FS_LOW_P 0.07132f
C441 PAD_P HS_P_8 1.09993f
C442 HS_N_11 PULLUP_P_OUT 0.03489f
C443 HS_N_9 TERM_GATE_P 0.13605f
C444 HS_P PULLUP_N_BLEED_6 0.04828f
C445 PULLUP_P_BLEED_3 HS_PBIAS 0.04828f
C446 TERM_GATE_N_BLEED_0 HS_N_2 0.03489f
C447 HS_P_12 HS_N_11 0.06914f
C448 TERM_GATE_N_BLEED_1 HS_N_1 0.05286f
C449 TERM_OR_P_B HS_N_10 0.0738f
C450 HS_N_4 FS_P_BLEED_6 0.06178f
C451 HS_N PULLDOWN_N 0.05791f
C452 PULLUP_P FS_N_BLEED_1 0.04819f
C453 PULLUP_N_BLEED_5 TERM_P_R 0.11141f
C454 PULLUP_P_GATE HS_N_2 0.08296f
C455 HS_N_12 TERM_N_R 0.0597f
C456 HS_P_8 PULLUP_P_OUT 0.00135f
C457 HS_N_2 HS_N_1 0.00962f
C458 HS_N_3 HS_N_13 0.279f
C459 FS_P_BLEED_0 VCM_LOW_OK 0.15599f
C460 FS_N_BLEED_0 FS_HIGH_P 0.00106f
C461 PULLDOWN_P FS_N_BLEED_0 0.07407f
C462 FS_LOW_N FS_N_BLEED_6 0
C463 HS_N_0 HS_N_13 0.07993f
C464 HS_P_8 HS_P_12 0
C465 HS_N FS_P_BLEED_3 0.0463f
C466 TERM_OR_N_NS HS_N_12 0.03425f
C467 DIV_LOW_P TERM_P_R 0.00106f
C468 HS_N_12 HS_P 0.78589f
C469 DIV_LOW_P FS_P_OUT 0.13605f
C470 TERM_VCM FS_LOW_P 0.24801f
C471 PULLUP_N_BLEED_5 PULLUP_N_BLEED_2 0.00296f
C472 ESD_RAIL a_41005_133505# 0.53842f
C473 HS_N DIV_LOW_N 0.08856f
C474 HS_PBIAS TERM_GATE_N_BLEED_0 0.04828f
C475 HS_P_1 HS_N_1 0.09066f
C476 TERM_GATE_N HS_N_11 0.04856f
C477 TERM_OR_P_B HS_P_9 0.1442f
C478 FS_P_BLEED_1 TERM_P_R 0.04766f
C479 PULLUP_N_BLEED_5 PULLUP_N_BLEED_3 0.10602f
C480 FS_N_BLEED_4 TERM_P_R 0.04766f
C481 FS_P_BLEED_1 FS_P_OUT 0
C482 FS_HIGH_N DIFF_ENABLE 0.2667f
C483 HS_N_6 FS_P_BLEED_0 0.06178f
C484 HS_N_12 HS_P_13 0.02465f
C485 HS_N FS_N_BLEED_2 0.11535f
C486 FS_P_BLEED_5 HS_N_11 0.06178f
C487 PULLUP_P_GATE HS_PBIAS 0.17404f
C488 TERM_GATE_N_BLEED_1 FS_N_OUT 0.06408f
C489 PULLDOWN_P_R FS_P_OUT 0.73833f
C490 HS_PBIAS HS_N_1 2.51285f
C491 HS_P_11 HS_P_10 48.3384f
C492 PULLDOWN_P_R TERM_P_R 0.16322f
C493 HS_N_13 HS_N_10 0.09129f
C494 FS_N_CONTROL_S PULLUP_N_OUT 0.10706f
C495 FS_N_WELL TERM_P_R 1.29698f
C496 TERM_ENABLE FS_N_GATE 0.97699f
C497 FS_P_OUT PULLDOWN_N_R 0.68986f
C498 HS_P_11 PULLUP_N_OUT 0.08824f
C499 PULLDOWN_N_R TERM_P_R 0.14117f
C500 PULLUP_N_OUT FS_LOW_N 0.06432f
C501 PULLDOWN_N DIFF_ENABLE 0.37137f
C502 FS_P_BLEED_0 VDD 0.66399f
C503 HS_P_10 HS_P_0 2.2381f
C504 HS_N_1 HS_P_5 0.03489f
C505 TERM_N_R VCM_LOW_OK 0.18442f
C506 PULLUP_P_WELL FS_HIGH_P 0.27585f
C507 FS_N_GATE HS_N_9 0.01367f
C508 PAD_N HS_N_8 1.07245f
C509 TERM_GATE_P_BLEED_0 TERM_N_R 0.14463f
C510 TERM_ENABLE HS_N_11 0.04853f
C511 HS_P_10 HS_N_5 0.03089f
C512 TERM_ENABLE PULLUP_P_BLEED_5 0
C513 HS_P_0 PULLUP_N_OUT 0.09237f
C514 HS_N_8 HS_N_7 0.11965p
C515 PULLUP_P_BLEED_5 HS_N_9 0.04943f
C516 FS_P_BLEED_4 PULLUP_N_OUT 0
C517 HS_N_9 HS_N_11 0.02558f
C518 PULLUP_N_OUT HS_N_5 0.04773f
C519 FS_P_GATE HS_N_2 1.03585f
C520 HS_N_4 TERM_GATE_N_BLEED_1 0.0525f
C521 PULLUP_N_BLEED_2 PULLDOWN_N_R 0.05146f
C522 TERM_GATE_N_BLEED_2 HS_N_12 0.02427f
C523 HS_N FS_N_BLEED_0 0.11535f
C524 TERM_OR_N_NS VCM_LOW_OK 7.88232f
C525 HS_P VCM_LOW_OK 0.06526f
C526 TERM_GATE_P_BLEED_0 HS_P 0.00154f
C527 TERM_N_R PULLUP_N_BLEED_4 0.05729f
C528 PULLUP_N_BLEED_3 PULLDOWN_N_R 0.00237f
C529 HS_N_13 TERM_OR_N_S 0.02464f
C530 PULLUP_P_BLEED_4 HS_N_2 0.0525f
C531 PULLUP_P_BLEED_5 PULLUP_P_BLEED_6 3.1342f
C532 HS_N_6 TERM_N_R 0.1093f
C533 HS_N_3 FS_HIGH_P 0.02404f
C534 TERM_ENABLE HS_P_8 0.02404f
C535 PULLUP_N_BLEED_0 VDD 0
C536 HS_N_13 FS_P_CONTROL_S 0.03226f
C537 TERM_GATE_P_BLEED_0 HS_P_13 0.0256f
C538 FS_N_CONTROL_S TERM_VCM 0.07594f
C539 DIV_LOW_P TERM_GATE_P 0.00428f
C540 HS_P_13 VCM_LOW_OK 0.03489f
C541 HS_N_8 PULLUP_P 0.02404f
C542 DIV_N TERM_N_R 0.14748f
C543 HS_N_0 FS_HIGH_P 0.02438f
C544 HS_N_4 HS_N_2 0.00206f
C545 PULLDOWN_N_R TERM_OR_N_B 0.04207f
C546 HS_P_8 HS_N_9 0.10431f
C547 HS_P_11 TERM_VCM 0.13824f
C548 FS_LOW_N TERM_VCM 0.11348f
C549 HS_N_0 PULLDOWN_P 0.04428f
C550 FS_N_BLEED_3 FS_HIGH_P 0
C551 HS_PBIAS FS_N_OUT 0.93576f
C552 FS_N_BLEED_3 PULLDOWN_P 0.08856f
C553 PAD_N HS_N_7 1.7635f
C554 PULLUP_N_OUT FS_P_WELL 2.65652f
C555 TERM_OR_N_NS HS_N_6 0.03425f
C556 HS_N_6 HS_P 1.04391f
C557 HS_P_0 TERM_VCM 0.19537f
C558 HS_P_6 TERM_P_R 0.08356f
C559 TERM_OR_N_NS DIV_N 0
C560 TERM_N_R VDD 6.88046f
C561 FS_P_OUT HS_P_6 0.15673f
C562 FS_P_GATE HS_PBIAS 1.80592f
C563 DIV_N HS_P 0.03732f
C564 PULLDOWN_P_R TERM_GATE_P 0.30143f
C565 FS_N_CONTROL_S FS_LOW_P 0.04634f
C566 HS_P_5 FS_N_OUT 0.06167f
C567 PAD_P HS_P_10 1.26307f
C568 TERM_P_R PULLUP_N_CONTROL_S 0.0414f
C569 HS_N_4 HS_P_1 0.0586f
C570 PULLUP_P_BLEED_3 PULLUP_P_BLEED_2 3.88784f
C571 HS_N_8 HS_P_7 0.09182f
C572 HS_P_11 FS_LOW_P 0.05239f
C573 FS_P_BLEED_3 FS_P_BLEED_6 0.12236f
C574 HS_N_5 TERM_VCM 0.12535f
C575 HS_P_4 VCM_LOW_OK 0.06673f
C576 HS_N_6 HS_P_13 0.05493f
C577 FS_LOW_N FS_LOW_P 93.3684f
C578 TERM_GATE_P_BLEED_0 HS_P_4 0.02451f
C579 PULLUP_P_BLEED_4 HS_PBIAS 0.07928f
C580 PULLDOWN_N_R TERM_GATE_P 0.26213f
C581 PAD_P PULLUP_N_OUT 0.11127f
C582 PULLUP_P HS_N_7 0.07466f
C583 HS_P_0 FS_LOW_P 0.0932f
C584 HS_N_10 FS_HIGH_P 0.02442f
C585 TERM_OR_N_NS VDD 0.44386f
C586 HS_P VDD 1.62825f
C587 PAD_N DIV_P 0.47479f
C588 HS_N PULLUP_P_WELL 0.29467f
C589 HS_N_4 HS_PBIAS 2.61651f
C590 HS_P_10 PULLUP_P_OUT 0.05276f
C591 HS_N_5 FS_LOW_P 0.08533f
C592 HS_P_13 VDD 6.64318f
C593 PAD_N HS_P_7 0.3613f
C594 HS_N HS_P_2 0.46352f
C595 FS_P_WELL TERM_VCM 1.40942f
C596 PULLUP_N_OUT PULLUP_P_OUT 0.17355f
C597 HS_P_4 HS_N_6 0.03738f
C598 HS_P_10 HS_P_12 0.07589f
C599 HS_N_8 HS_P_3 0.02404f
C600 HS_N_4 HS_P_5 0.03511f
C601 PULLUP_P_CONTROL_S HS_P 0.04808f
C602 HS_N_7 HS_P_7 0
C603 PULLUP_N_GATE FS_N_BLEED_5 0
C604 PULLUP_N_OUT HS_P_12 0.03006f
C605 HS_N HS_N_3 2.40305f
C606 TERM_OR_P_NS HS_P_1 0.04312f
C607 TERM_GATE_N_BLEED_2 HS_N_6 0.03334f
C608 HS_N HS_N_0 0.13467p
C609 PAD_P TERM_VCM 0.0037f
C610 FS_P_WELL FS_LOW_P 1.90293f
C611 PULLDOWN_P PULLUP_N 5.21685f
C612 TERM_OR_P_B TERM_N_R 1.12426f
C613 HS_P_4 VDD 4.77123f
C614 PULLDOWN_P TERM_OR_N_S 0.10193f
C615 HS_N FS_N_BLEED_3 0.11535f
C616 FS_P_CONTROL_S FS_HIGH_P 0.51548f
C617 HS_N_13 FS_P_BLEED_0 0.06178f
C618 PULLUP_P_GATE PULLUP_P_BLEED_2 0.1764f
C619 DIV_ENABLE HS_N_8 0.03089f
C620 PAD_N HS_P_3 0.257f
C621 FS_N_GATE FS_N_BLEED_4 0.27893f
C622 PULLUP_N_WELL PULLUP_N_BLEED_1 0.00587f
C623 DIV_LOW_P HS_N_11 0.00184f
C624 HS_P_6 TERM_GATE_P 0.15508f
C625 FS_P_BLEED_1 HS_N_11 0.03472f
C626 TERM_N_R TERM_OR_P_S 0.0546f
C627 TERM_OR_P_B HS_P 0.0917f
C628 TERM_VCM PULLUP_P_OUT 0.36501f
C629 PAD_P ESD_RAIL 24.1165f
C630 FS_N_GATE FS_N_WELL 0.2903p
C631 HS_PBIAS PULLUP_N_WELL 0.42834f
C632 PULLUP_P_BLEED_3 TERM_P_R 0.04766f
C633 PULLUP_N_OUT TERM_GATE_N 0.23412f
C634 TERM_OR_P_NS HS_P_5 0.02846f
C635 FS_N_GATE PULLDOWN_N_R 1.16382f
C636 TERM_OR_P_B HS_P_13 0.10389f
C637 TERM_VCM HS_P_12 0.107f
C638 HS_P_11 HS_P_0 0.06445f
C639 PULLDOWN_P_R HS_N_11 0.02429f
C640 FS_N_WELL HS_N_11 0.00889f
C641 FS_P_BLEED_5 PULLUP_N_OUT 0.05922f
C642 PAD_N DIV_ENABLE 0.03382f
C643 PULLDOWN_P_R PULLUP_P_BLEED_5 0.09218f
C644 HS_N HS_N_10 3.58671f
C645 DIV_ENABLE HS_N_7 0.03089f
C646 HS_P_11 HS_N_5 0.03089f
C647 HS_N_11 PULLDOWN_N_R 0.06159f
C648 PULLUP_P_OUT FS_LOW_P 0.17673f
C649 FS_LOW_N HS_N_5 0.08469f
C650 PULLUP_P_BLEED_5 PULLDOWN_N_R 0.09196f
C651 HS_PBIAS FS_HIGH_N 0.03743f
C652 PULLUP_N_GATE PULLUP_N_WELL 33.5703f
C653 HS_P_12 FS_LOW_P 0.17418f
C654 FS_P_BLEED_3 HS_N_2 0.02846f
C655 HS_P_0 HS_N_5 0.03733f
C656 TERM_ENABLE HS_P_10 0.0768f
C657 HS_P_8 PULLDOWN_P_R 0.08554f
C658 DIV_LOW_N HS_N_2 0.06178f
C659 TERM_OR_P_B HS_P_4 0.10189f
C660 HS_P_10 HS_N_9 0.03109f
C661 DIV_ENABLE PULLUP_P 0.05123f
C662 FS_P_BLEED_4 HS_N_5 0.06219f
C663 HS_N_13 TERM_N_R 0.10989f
C664 HS_N_8 HS_N_12 0.03497f
C665 HS_P_3 HS_P_7 0.06116f
C666 TERM_ENABLE PULLUP_N_OUT 0.19202f
C667 TERM_GATE_N_BLEED_0 TERM_P_R 0.04766f
C668 HS_P_8 PULLDOWN_N_R 0.06544f
C669 RX_N FS_P_OUT 0.00505f
C670 PULLUP_P_WELL FS_P_BLEED_6 0.01133f
C671 HS_N_9 PULLUP_N_OUT 0.01492f
C672 TERM_GATE_N TERM_VCM 24.8972f
C673 HS_PBIAS PULLDOWN_N 0.03743f
C674 HS_N TERM_OR_N_S 0.07589f
C675 HS_N HS_P_9 0.12189f
C676 PULLUP_N_GATE FS_HIGH_N 0.01195f
C677 DIV_ENABLE DIV_P 4.76769f
C678 TERM_OR_N_NS HS_N_13 0.03425f
C679 HS_N_13 HS_P 0.10519f
C680 PULLUP_P_GATE TERM_P_R 0.15811f
C681 PULLUP_P_BLEED_0 PULLUP_P_BLEED_2 0.10891f
C682 HS_N FS_P_CONTROL_S 0.04342f
C683 FS_N_BLEED_1 VDD 0.00299f
C684 HS_N_1 TERM_P_R 0.06087f
C685 PULLUP_P PULLUP_N_BLEED_6 0.05764f
C686 FS_P_OUT HS_N_1 0.44686f
C687 PULLUP_P_BLEED_6 PULLUP_N_OUT 0.09268f
C688 PULLUP_P_BLEED_4 PULLUP_P_BLEED_2 0
C689 FS_P_BLEED_0 FS_HIGH_P 0.23079f
C690 HS_N_13 HS_P_13 0.0245f
C691 PAD_N HS_N_12 1.21768f
C692 FS_P_OUT FS_P_BLEED_2 0
C693 TERM_GATE_N FS_LOW_P 0.04939f
C694 HS_N_5 FS_P_WELL 1.97115f
C695 FS_P_BLEED_3 HS_PBIAS 0.07855f
C696 PAD_P HS_P_11 1.25724f
C697 HS_N_3 FS_P_BLEED_6 0.06178f
C698 HS_N_7 HS_N_12 0.02955f
C699 PULLUP_N_GATE PULLDOWN_N 0.00151f
C700 a_42245_90628# ESD_RAIL 0.24367p
C701 DIV_LOW_N HS_PBIAS 0.09646f
C702 HS_P_6 HS_N_11 0.05932f
C703 PAD_P HS_P_0 1.64024f
C704 HS_N_0 FS_P_BLEED_6 0.06178f
C705 TERM_ENABLE TERM_VCM 0.55788f
C706 TERM_GATE_N_BLEED_0 TERM_OR_N_B 0.00163f
C707 HS_N_9 TERM_VCM 0.14022f
C708 PAD_P HS_N_5 0.34243f
C709 HS_P_11 PULLUP_P_OUT 0.05519f
C710 FS_N_BLEED_2 HS_PBIAS 0.08856f
C711 TERM_GATE_P_BLEED_0 HS_N_8 0
C712 PULLUP_P HS_N_12 0.0678f
C713 PULLUP_N_BLEED_0 FS_HIGH_P 0.01347f
C714 HS_N_8 VCM_LOW_OK 0.05893f
C715 PULLDOWN_P PULLUP_N_BLEED_0 0.06517f
C716 HS_P_8 HS_P_6 0.00206f
C717 HS_P_11 HS_P_12 46.9655f
C718 PULLUP_N DIFF_ENABLE 0.26007f
C719 TERM_ENABLE FS_LOW_P 0.13548f
C720 FS_P_BLEED_4 PULLUP_P_OUT 0.00257f
C721 HS_N_9 FS_LOW_P 0.08576f
C722 TERM_GATE_N_BLEED_2 HS_N_13 0.02404f
C723 HS_N_5 PULLUP_P_OUT 0.03489f
C724 TERM_GATE_P_BLEED_0 TERM_GATE_P_BLEED_1 2.63577f
C725 HS_P_0 HS_P_12 0.08899f
C726 FS_N_OUT TERM_P_R 0.3082f
C727 HS_N_10 FS_P_BLEED_6 0.06178f
C728 FS_P_OUT FS_N_OUT 1.00178f
C729 HS_N_5 HS_P_12 0.06578f
C730 TERM_N_R FS_HIGH_P 0.01124f
C731 HS_N_8 HS_N_6 0.04151f
C732 PULLDOWN_P TERM_N_R 0.20782f
C733 FS_P_GATE TERM_P_R 0.79885f
C734 FS_P_GATE FS_P_OUT 0.13406p
C735 HS_N_8 DIV_N 0.03462f
C736 HS_N_7 VCM_LOW_OK 0.05893f
C737 HS_N_1 TERM_GATE_P 0.10974f
C738 HS_PBIAS FS_N_BLEED_0 0.10276f
C739 TERM_GATE_P_BLEED_0 HS_N_7 0
C740 TERM_OR_N_NS FS_HIGH_P 0.00369f
C741 HS_P FS_HIGH_P 0.02404f
C742 DIV_ENABLE PULLUP_N_BLEED_6 0.03269f
C743 FS_P_WELL PULLUP_P_OUT 3.0456f
C744 HS_N FS_P_BLEED_0 0.07763f
C745 PULLDOWN_P TERM_OR_N_NS 0.04764f
C746 FS_LOW_N TERM_GATE_N 0.09048f
C747 HS_N_8 VDD 4.98108f
C748 HS_P_3 HS_N_12 0.02482f
C749 HS_N_4 TERM_P_R 0.05893f
C750 PULLUP_P_WELL HS_N_2 0.11473f
C751 HS_N_4 FS_P_OUT 0.43331f
C752 FS_P_WELL HS_P_12 0.00134f
C753 PULLUP_P VCM_LOW_OK 0.08753f
C754 PAD_N HS_N_6 1.1595f
C755 ESD_RAIL a_41005_131545# 96.5489f
C756 PAD_N DIV_N 0.68859f
C757 HS_N_7 HS_N_6 0.12041p
C758 PULLUP_P_BLEED_3 HS_N_11 0.03489f
C759 HS_P_2 HS_N_2 0.06704f
C760 TERM_GATE_N_BLEED_1 HS_N_3 0.0525f
C761 TERM_GATE_N HS_N_5 0.04924f
C762 FS_P_BLEED_1 PULLUP_N_OUT 0.06151f
C763 PAD_P PULLUP_P_OUT 0.43807f
C764 PULLUP_P_BLEED_3 PULLUP_P_BLEED_5 0.00153f
C765 FS_N_BLEED_4 PULLUP_N_OUT 0.05445f
C766 VDD TERM_GATE_P_BLEED_1 0.07121f
C767 DIV_P VCM_LOW_OK 0.00892f
C768 HS_N_7 DIV_N 0.03462f
C769 HS_N_0 TERM_GATE_N_BLEED_1 0.05293f
C770 PULLUP_P_CONTROL_S HS_N_8 0.04808f
C771 HS_N PULLUP_N_BLEED_0 0.12943f
C772 FS_P_BLEED_5 HS_N_5 0.06178f
C773 PULLDOWN_P_R HS_P_10 0.07466f
C774 FS_P_BLEED_4 FS_P_BLEED_5 3.61839f
C775 TERM_ENABLE FS_N_CONTROL_S 0.12118f
C776 PAD_P HS_P_12 1.66835f
C777 PULLUP_P PULLUP_N_BLEED_4 0.10721f
C778 DIV_ENABLE HS_N_12 0.03143f
C779 TERM_ENABLE FS_LOW_N 0.37409f
C780 PAD_N VDD 0.00457f
C781 TERM_GATE_P_BLEED_0 HS_P_7 0.02404f
C782 PULLUP_N_BLEED_5 TERM_VCM 0.13759f
C783 TERM_ENABLE HS_P_11 0.07923f
C784 HS_N_3 HS_N_2 0.12365p
C785 HS_P_7 VCM_LOW_OK 0.03489f
C786 HS_P_10 PULLDOWN_N_R 0.07466f
C787 PULLDOWN_P_R PULLUP_N_OUT 0.10143f
C788 PULLUP_N_OUT FS_N_WELL 2.10234f
C789 PULLUP_P HS_N_6 0.07466f
C790 HS_P_11 HS_N_9 0.03103f
C791 HS_N_0 HS_N_2 0.04171f
C792 HS_P_1 HS_P_2 0.0568f
C793 FS_N_OUT TERM_GATE_P 0.1125f
C794 HS_N_7 VDD 5.51673f
C795 PULLUP_N_OUT PULLDOWN_N_R 0.08331f
C796 HS_N_9 FS_LOW_N 0.08512f
C797 PULLUP_P DIV_N 0.04512f
C798 TERM_ENABLE HS_P_0 0.03037f
C799 HS_PBIAS PULLUP_P_WELL 0.52241f
C800 TERM_OR_P_NS TERM_P_R 0.22589f
C801 HS_P_0 HS_N_9 0.03791f
C802 HS_N TERM_N_R 0.14159f
C803 PULLUP_P_BLEED_6 FS_LOW_N 0.02395f
C804 DIV_LOW_P TERM_VCM 0.00257f
C805 DIV_P DIV_N 48.6079f
C806 TERM_ENABLE HS_N_5 0.08996f
C807 FS_P_BLEED_4 HS_N_9 0.06295f
C808 TERM_GATE_N_BLEED_0 HS_N_11 0.03489f
C809 TERM_GATE_N_BLEED_1 HS_N_10 0.0527f
C810 TERM_GATE_N_BLEED_2 PULLDOWN_P 0.07928f
C811 HS_PBIAS HS_P_2 3.95109f
C812 HS_N_9 HS_N_5 0.04079f
C813 PULLUP_P VDD 2.22026f
C814 TERM_OR_P_B HS_N_8 0.07245f
C815 FS_N_BLEED_4 TERM_VCM 0.04263f
C816 PULLUP_P_CONTROL_S HS_N_7 0.04808f
C817 FS_P_BLEED_1 TERM_VCM 0.03472f
C818 HS_P_3 VCM_LOW_OK 0.09096f
C819 PULLUP_N_WELL TERM_P_R 0.29516f
C820 TERM_GATE_P_BLEED_0 HS_P_3 0.02464f
C821 HS_N TERM_OR_N_NS 0.04764f
C822 HS_N HS_P 2.27647f
C823 PULLUP_P_GATE HS_N_11 0.08345f
C824 HS_P_2 HS_P_5 0.03142f
C825 PULLUP_P_GATE PULLUP_P_BLEED_5 0.2056f
C826 HS_N_1 HS_N_11 0.03414f
C827 DIV_P VDD 0.11168f
C828 PULLUP_P_BLEED_6 HS_N_5 0
C829 HS_PBIAS HS_N_3 1.07017f
C830 HS_N_2 HS_N_10 0.03509f
C831 DIV_LOW_P FS_LOW_P 0.12545f
C832 TERM_OR_P_B TERM_GATE_P_BLEED_1 0.00371f
C833 HS_N_4 TERM_GATE_P 0.11218f
C834 PULLUP_P_BLEED_5 HS_N_1 0.02451f
C835 HS_N HS_P_13 0.35374f
C836 PULLDOWN_P_R TERM_VCM 0.22328f
C837 FS_N_WELL TERM_VCM 1.58767f
C838 HS_N_11 FS_P_BLEED_2 0
C839 TERM_ENABLE FS_P_WELL 2.50111f
C840 HS_N_0 HS_PBIAS 7.78201f
C841 PULLUP_P_CONTROL_S PULLUP_P 6.1629f
C842 FS_N_BLEED_4 FS_LOW_P 0.23267f
C843 FS_N_BLEED_3 HS_PBIAS 0.08856f
C844 FS_P_BLEED_1 FS_LOW_P 0.07139f
C845 PULLUP_N_BLEED_2 PULLUP_N_WELL 0.00114f
C846 HS_P_7 VDD 4.96081f
C847 TERM_VCM PULLDOWN_N_R 0.28542f
C848 FS_HIGH_N TERM_P_R 0.05398f
C849 DIV_ENABLE VCM_LOW_OK 0
C850 HS_N_9 FS_P_WELL 2.02035f
C851 HS_N_3 HS_P_5 0.03489f
C852 HS_P_3 HS_N_6 0.03089f
C853 HS_P_10 HS_P_6 0.07646f
C854 HS_N_0 HS_P_5 0.03489f
C855 PULLUP_N_WELL PULLUP_N_BLEED_3 0
C856 TERM_OR_P_B HS_N_7 0.07211f
C857 FS_P_BLEED_5 PULLUP_P_OUT 0.05047f
C858 PULLDOWN_P_R FS_LOW_P 0.06539f
C859 FS_N_WELL FS_LOW_P 1.46004f
C860 PULLUP_N_OUT HS_P_6 0.02846f
C861 PULLUP_N_OUT PULLUP_N_CONTROL_S 0.004f
C862 HS_N HS_P_4 0.15877f
C863 FS_N_BLEED_1 FS_HIGH_P 0
C864 PULLDOWN_N_R FS_LOW_P 0.0629f
C865 TERM_N_R DIFF_ENABLE 6.47766f
C866 PAD_P HS_N_9 1.20851f
C867 PULLDOWN_N TERM_P_R 0.05332f
C868 FS_N_BLEED_3 PULLUP_N_GATE 0
C869 HS_N_2 TERM_OR_N_S 0.02451f
C870 HS_PBIAS HS_N_10 1.13923f
C871 PULLDOWN_P FS_N_BLEED_1 0.09712f
C872 HS_N_8 HS_N_13 0.16699f
C873 HS_P_3 VDD 6.14484f
C874 DIV_ENABLE HS_N_6 0.03089f
C875 HS_N_2 FS_P_CONTROL_S 0.03226f
C876 FS_N_GATE FS_N_OUT 0.14435p
C877 DIV_ENABLE DIV_N 33.0875f
C878 TERM_ENABLE PULLUP_P_OUT 11.6132f
C879 HS_N TERM_GATE_N_BLEED_2 0.05048f
C880 DIFF_ENABLE HS_P 0.27285f
C881 TERM_VCM BYPASS_ENABLE 0.00889f
C882 HS_P_5 HS_N_10 0.03489f
C883 TERM_OR_P_B DIV_P 0.0223f
C884 HS_N_9 PULLUP_P_OUT 0.03516f
C885 PULLUP_N_BLEED_4 PULLUP_N_BLEED_6 0.00855f
C886 PULLUP_N PULLUP_N_BLEED_1 0.31155f
C887 HS_P_1 HS_P_9 0.03494f
C888 TERM_ENABLE HS_P_12 0.02404f
C889 DIV_ENABLE VDD 0.3424f
C890 FS_P_GATE HS_N_11 1.0396f
C891 DIV_LOW_N TERM_P_R 0.0414f
C892 HS_N_9 HS_P_12 0.06578f
C893 TERM_OR_P_B HS_P_7 0.10117f
C894 FS_N_GATE FS_N_BLEED_5 0.25656f
C895 TERM_VCM HS_P_6 0.09619f
C896 HS_N_12 VCM_LOW_OK 0.05893f
C897 PAD_N HS_N_13 1.56314f
C898 HS_PBIAS TERM_OR_N_S 0.12657f
C899 PULLUP_P_BLEED_5 PULLUP_P_BLEED_4 4.64605f
C900 PULLUP_P_BLEED_4 HS_N_11 0.05266f
C901 TERM_VCM PULLUP_N_CONTROL_S 0.0423f
C902 HS_PBIAS HS_P_9 3.39603f
C903 FS_P_BLEED_6 TERM_N_R 0.05729f
C904 HS_N_7 HS_N_13 0.09546f
C905 FS_N_BLEED_2 TERM_P_R 0.04588f
C906 HS_PBIAS FS_P_CONTROL_S 0.04861f
C907 FS_N_BLEED_4 FS_LOW_N 0.07141f
C908 HS_N_4 HS_N_11 0
C909 PULLUP_P_CONTROL_S DIV_ENABLE 0.00795f
C910 VDD PULLUP_N_BLEED_6 0.45117f
C911 HS_N_4 PULLUP_P_BLEED_5 0.02921f
C912 HS_P_9 HS_P_5 0
C913 HS_P_6 FS_LOW_P 0.04566f
C914 FS_N_CONTROL_S FS_N_WELL 0.9381f
C915 HS_P_11 PULLDOWN_P_R 0.07466f
C916 FS_P_BLEED_6 HS_P 0.06178f
C917 PULLDOWN_P_R FS_LOW_N 0.00223f
C918 HS_N_6 HS_N_12 0
C919 FS_P_BLEED_1 HS_N_5 0.03472f
C920 FS_LOW_N FS_N_WELL 0.90409f
C921 PULLUP_P HS_N_13 0.07466f
C922 TERM_ENABLE TERM_GATE_N 10.756f
C923 FS_N_CONTROL_S PULLDOWN_N_R 0.09439f
C924 TERM_OR_P_B HS_P_3 0.10238f
C925 PULLUP_N_GATE PULLUP_N 1.36429f
C926 PULLUP_P_BLEED_2 PULLUP_P_WELL 0
C927 FS_LOW_N PULLDOWN_N_R 0.05849f
C928 HS_N_9 TERM_GATE_N 0.05172f
C929 HS_N_12 DIV_N 0.03462f
C930 HS_P_11 PULLDOWN_N_R 0.07466f
C931 HS_N FS_N_BLEED_1 0.11535f
C932 PULLUP_P_BLEED_3 PULLUP_N_OUT 0.05476f
C933 PULLDOWN_P_R HS_P_0 0.03037f
C934 TERM_ENABLE FS_P_BLEED_5 0.00492f
C935 FS_P_BLEED_4 PULLDOWN_P_R 0.08089f
C936 PULLDOWN_P_R HS_N_5 0.02404f
C937 FS_P_BLEED_5 HS_N_9 0.06178f
C938 HS_P_0 PULLDOWN_N_R 0.03037f
C939 FS_P_BLEED_4 PULLDOWN_N_R 0.05822f
C940 RX_P PAD_N 3.07596f
C941 HS_N_2 FS_P_BLEED_0 0.06178f
C942 DIV_ENABLE TERM_OR_P_B 0
C943 HS_N_12 VDD 6.63266f
C944 HS_N_5 PULLDOWN_N_R 0.06832f
C945 HS_N_8 FS_HIGH_P 0.03528f
C946 PULLUP_P_BLEED_1 PULLUP_P_BLEED_2 2.37421f
C947 FS_P_BLEED_1 FS_P_WELL 0.02734f
C948 TERM_ENABLE HS_N_9 0.04808f
C949 PULLUP_P_CONTROL_S HS_N_12 0.04885f
C950 PULLDOWN_P_R FS_P_WELL 3.25452f
C951 PULLUP_N_OUT TERM_GATE_N_BLEED_0 0.05462f
C952 a_42245_90628# a_41005_131545# 0.0135f
C953 PULLUP_P_BLEED_3 TERM_VCM 0.03472f
C954 FS_P_WELL PULLDOWN_N_R 2.83843f
C955 TERM_ENABLE PULLUP_P_BLEED_6 0
C956 HS_P_3 HS_N_13 0.02464f
C957 HS_N_6 VCM_LOW_OK 0.05893f
C958 HS_P_10 HS_N_1 0.0348f
C959 TERM_OR_P_NS HS_P_8 0.02846f
C960 FS_N_GATE FS_HIGH_N 8.87893f
C961 TERM_GATE_P_BLEED_0 HS_N_6 0
C962 PULLUP_P_GATE PULLUP_N_OUT 0.36087f
C963 RX_P DIV_P 1.39534f
C964 HS_N_7 FS_HIGH_P 0.02404f
C965 PULLUP_P_BLEED_6 HS_N_9 0.00148f
C966 TERM_GATE_N_BLEED_1 TERM_N_R 0.07874f
C967 DIV_N VCM_LOW_OK 0.00178f
C968 HS_P_11 HS_P_6 0.06713f
C969 PULLDOWN_P HS_N_7 0.04428f
C970 HS_PBIAS FS_P_BLEED_0 0.08856f
C971 PAD_P PULLDOWN_P_R 2.92129f
C972 PULLUP_P_BLEED_3 FS_LOW_P 0.07139f
C973 PAD_P PULLDOWN_N_R 1.40429f
C974 FS_P_BLEED_1 PULLUP_P_OUT 0.05902f
C975 HS_P_0 HS_P_6 0.04603f
C976 PULLUP_P_WELL TERM_P_R 0.29295f
C977 TERM_OR_P_B HS_N_12 0.07307f
C978 DIV_ENABLE HS_N_13 0.03089f
C979 TERM_GATE_N_BLEED_1 HS_P 0.0525f
C980 VDD VCM_LOW_OK 57.507f
C981 HS_N_2 TERM_N_R 0.0594f
C982 TERM_GATE_P_BLEED_0 VDD 0.12131f
C983 PULLUP_N_BLEED_0 PULLUP_N_BLEED_1 3.40429f
C984 PULLUP_P FS_HIGH_P 0.06616f
C985 HS_N_5 HS_P_6 0.05828f
C986 PULLDOWN_P_R PULLUP_P_OUT 0.13835f
C987 HS_P_2 TERM_P_R 0.08491f
C988 PULLDOWN_P PULLUP_P 0.05412f
C989 HS_N_6 DIV_N 0.03462f
C990 TERM_GATE_N_BLEED_0 TERM_VCM 0.04263f
C991 FS_P_WELL BYPASS_ENABLE 0.05062f
C992 PULLUP_P_OUT PULLDOWN_N_R 0.10342f
C993 HS_PBIAS PULLUP_N_BLEED_0 0.07928f
C994 PULLDOWN_P_R HS_P_12 0.02404f
C995 TERM_OR_N_NS HS_N_2 0.03425f
C996 HS_N_2 HS_P 0.85293f
C997 HS_N HS_N_8 2.66346f
C998 FS_N_BLEED_5 FS_N_BLEED_6 1.15313f
C999 PULLUP_N_BLEED_4 VDD 0.0157f
C1000 HS_N_3 TERM_P_R 0.05893f
C1001 FS_P_OUT HS_N_3 0.48792f
C1002 PULLUP_P_GATE TERM_VCM 0.12603f
C1003 HS_N_6 VDD 6.90044f
C1004 PULLUP_P_BLEED_1 TERM_P_R 0.04588f
C1005 HS_P_12 PULLDOWN_N_R 0.02404f
C1006 HS_N_2 HS_P_13 0.07762f
C1007 HS_N_1 TERM_VCM 0.12324f
C1008 HS_N_0 TERM_P_R 0.10318f
C1009 HS_N_0 FS_P_OUT 0.5609f
C1010 TERM_GATE_N_BLEED_0 FS_LOW_P 0.06271f
C1011 FS_P_BLEED_3 HS_N_11 0.029f
C1012 DIV_N VDD 0.3598f
C1013 FS_N_BLEED_3 TERM_P_R 0.11141f
C1014 PAD_P BYPASS_ENABLE 8.2284f
C1015 PULLUP_N_OUT FS_N_OUT 0.50078f
C1016 TERM_N_R TERM_GATE_P_BLEED_2 0.8432f
C1017 HS_P_1 HS_P 4.17389f
C1018 HS_PBIAS TERM_N_R 0.70629f
C1019 DIV_LOW_N HS_N_11 0.06178f
C1020 PULLUP_N_GATE PULLUP_N_BLEED_0 0.05192f
C1021 FS_N_BLEED_2 FS_N_GATE 0.19042f
C1022 PULLUP_N_BLEED_1 HS_P 0.11785f
C1023 PULLUP_P_GATE FS_LOW_P 0.15193f
C1024 PULLUP_P_CONTROL_S HS_N_6 0.04808f
C1025 TERM_ENABLE PULLUP_N_BLEED_5 0.11535f
C1026 PAD_N HS_N 35.6371f
C1027 RX_P DIV_ENABLE 0.88297f
C1028 FS_P_GATE PULLUP_N_OUT 1.30807f
C1029 PAD_P HS_P_6 1.8306f
C1030 HS_P_1 HS_P_13 0.11352f
C1031 HS_N_1 FS_LOW_P 0.21255f
C1032 PULLUP_P_CONTROL_S DIV_N 0.06087f
C1033 HS_N_13 HS_N_12 0.1359p
C1034 HS_PBIAS TERM_OR_N_NS 0.04764f
C1035 TERM_OR_P_B VCM_LOW_OK 2.10826f
C1036 HS_PBIAS HS_P 0.16546p
C1037 PULLUP_P_BLEED_0 PULLUP_N_OUT 0.04637f
C1038 TERM_GATE_P_BLEED_0 TERM_OR_P_B 0.0048f
C1039 HS_N HS_N_7 0.69419f
C1040 TERM_GATE_N_BLEED_2 TERM_GATE_N_BLEED_1 5.57305f
C1041 PULLUP_P_BLEED_4 PULLUP_N_OUT 0.09196f
C1042 FS_P_BLEED_2 FS_LOW_P 0.0781f
C1043 PULLUP_P_BLEED_3 FS_LOW_N 0.00876f
C1044 FS_P_OUT HS_N_10 0.44249f
C1045 TERM_GATE_N PULLDOWN_N_R 0.12021f
C1046 HS_N_10 TERM_P_R 0.06034f
C1047 HS_N_4 HS_P_10 0.07706f
C1048 PULLDOWN_P_R FS_P_BLEED_5 0.11255f
C1049 PULLUP_N_GATE TERM_N_R 0.17473f
C1050 HS_PBIAS HS_P_13 2.35188f
C1051 PULLUP_P_CONTROL_S VDD 4.743f
C1052 HS_P_5 HS_P 5.05127f
C1053 TERM_OR_P_S VCM_LOW_OK 1.87902f
C1054 HS_P_2 TERM_GATE_P 0.15718f
C1055 FS_P_BLEED_5 PULLDOWN_N_R 0.10378f
C1056 HS_N_4 PULLUP_N_OUT 0.01742f
C1057 HS_N PULLUP_P 0.03743f
C1058 TERM_GATE_N_BLEED_2 HS_N_2 0.02404f
C1059 TERM_ENABLE FS_N_BLEED_4 0.06151f
C1060 TERM_ENABLE FS_P_BLEED_1 0.05902f
C1061 TERM_VCM FS_N_OUT 0.42885f
C1062 HS_P_4 HS_P_1 0.03207f
C1063 HS_P_6 HS_P_12 0.07018f
C1064 PULLUP_N_GATE HS_P 0.11746f
C1065 TERM_OR_P_B HS_N_6 0.07211f
C1066 PULLUP_P_BLEED_3 HS_N_5 0.03489f
C1067 FS_P_BLEED_1 HS_N_9 0.03472f
C1068 HS_P_5 HS_P_13 0.26928f
C1069 DIV_ENABLE FS_HIGH_P 4.86998f
C1070 FS_N_GATE FS_N_BLEED_0 0.40602f
C1071 HS_N DIV_P 0.08005f
C1072 PULLUP_N_WELL FS_N_BLEED_6 0
C1073 DIV_ENABLE PULLDOWN_P 0.04428f
C1074 TERM_OR_P_B DIV_N 0.00135f
C1075 HS_N_3 TERM_GATE_P 0.11104f
C1076 TERM_ENABLE PULLDOWN_P_R 0.08114f
C1077 TERM_ENABLE FS_N_WELL 2.50751f
C1078 FS_P_GATE TERM_VCM 0.64724f
C1079 PULLUP_N TERM_P_R 0.07457f
C1080 PULLDOWN_P_R HS_N_9 0.02404f
C1081 HS_PBIAS HS_P_4 8.54683f
C1082 HS_N HS_P_7 0.15132f
C1083 TERM_ENABLE PULLDOWN_N_R 0.07871f
C1084 HS_N_9 FS_N_WELL 0.00889f
C1085 HS_N_0 TERM_GATE_P 0.11083f
C1086 TERM_P_R TERM_OR_N_S 0.30551f
C1087 FS_N_OUT FS_LOW_P 0.5386f
C1088 HS_P_9 TERM_P_R 0.11568f
C1089 FS_HIGH_P PULLUP_N_BLEED_6 0.08992f
C1090 HS_N_9 PULLDOWN_N_R 0.02404f
C1091 FS_LOW_N TERM_GATE_N_BLEED_0 0.07127f
C1092 TERM_OR_P_B VDD 16.0128f
C1093 PULLDOWN_P PULLUP_N_BLEED_6 0.04122f
C1094 FS_P_OUT FS_P_CONTROL_S 0
C1095 TERM_OR_P_NS HS_P_10 0.04329f
C1096 PULLDOWN_P_R PULLUP_P_BLEED_6 0.19409f
C1097 HS_N_13 VCM_LOW_OK 0.05893f
C1098 HS_P_4 HS_P_5 32.9896f
C1099 TERM_GATE_N_BLEED_2 HS_PBIAS 0.17672f
C1100 FS_P_GATE FS_LOW_P 0.55919f
C1101 TERM_OR_P_NS PULLUP_N_OUT 0.11021f
C1102 a_44789_117064# a_43813_117064# 2.94235f
C1103 HS_N_4 TERM_VCM 0.12411f
C1104 PULLUP_P_BLEED_6 PULLDOWN_N_R 0.05779f
C1105 HS_P_11 HS_N_1 0.02846f
C1106 PULLUP_N PULLUP_N_BLEED_2 0.29902f
C1107 HS_N_8 FS_P_BLEED_6 0.06178f
C1108 TERM_GATE_N_BLEED_0 HS_N_5 0.03489f
C1109 FS_LOW_N HS_N_1 0.12614f
C1110 PULLUP_P_BLEED_4 FS_LOW_P 0.0781f
C1111 VDD TERM_OR_P_S 4.39982f
C1112 PULLUP_N PULLUP_N_BLEED_3 0.121f
C1113 PULLUP_N_OUT PULLUP_N_WELL 30.7254f
C1114 FS_N_BLEED_5 FS_LOW_P 0.12388f
C1115 HS_N HS_P_3 0.27803f
C1116 HS_P_0 HS_N_1 0.04113f
C1117 HS_N_10 TERM_GATE_P 0.10903f
C1118 PULLUP_P_GATE HS_N_5 0.08413f
C1119 PULLUP_P_GATE FS_P_BLEED_4 0
C1120 PULLUP_P DIFF_ENABLE 0.20063f
C1121 HS_N_4 FS_LOW_P 0.08505f
C1122 HS_N_12 FS_HIGH_P 0.02428f
C1123 FS_P_BLEED_4 HS_N_1 0.06178f
C1124 HS_N_5 HS_N_1 0
C1125 HS_N_6 HS_N_13 0.08101f
C1126 PULLDOWN_P HS_N_12 0.04428f
C1127 TERM_OR_N_S TERM_OR_N_B 4.08319f
C1128 HS_N_13 DIV_N 0.03462f
C1129 FS_P_BLEED_4 FS_P_BLEED_2 0.12224f
C1130 PULLUP_N_OUT FS_HIGH_N 0.04377f
C1131 PULLUP_P_WELL HS_N_11 0.13224f
C1132 TERM_ENABLE HS_P_6 0.02404f
C1133 HS_N_7 FS_P_BLEED_6 0.06178f
C1134 HS_N DIV_ENABLE 0.05802f
C1135 m2_42279_124800# a_41005_131825# 0
C1136 TERM_OR_P_NS TERM_VCM 0.00155f
C1137 TERM_ENABLE PULLUP_N_CONTROL_S 0.07644f
C1138 HS_N_13 VDD 7.11098f
C1139 HS_N_9 HS_P_6 0.05493f
C1140 FS_N_CONTROL_S FS_N_OUT 0.01993f
C1141 HS_N_1 FS_P_WELL 2.10428f
C1142 HS_PBIAS FS_N_BLEED_1 0.08856f
C1143 PULLUP_P_BLEED_2 TERM_N_R 0.11444f
C1144 HS_P_9 TERM_GATE_P 0.22051f
C1145 TERM_VCM PULLUP_N_WELL 0.36125f
C1146 HS_N PULLUP_N_BLEED_6 0.06167f
C1147 RX_N PAD_P 0.47227f
C1148 FS_LOW_N FS_N_OUT 0.31306f
C1149 FS_P_WELL FS_P_BLEED_2 0.00213f
C1150 FS_N_BLEED_3 FS_N_GATE 0.19336f
C1151 HS_N_3 HS_N_11 0.03962f
C1152 PULLUP_P_BLEED_5 HS_N_3 0.02807f
C1153 TERM_OR_P_B TERM_OR_P_S 1.83456f
C1154 PULLUP_P_CONTROL_S HS_N_13 0.04867f
C1155 TERM_OR_P_NS FS_LOW_P 0.39723f
C1156 HS_N_0 PULLUP_P_BLEED_5 0.02492f
C1157 HS_N_0 HS_N_11 0.0421f
C1158 HS_P_8 HS_P_2 0.03103f
C1159 FS_P_BLEED_4 FS_N_OUT 0.06639f
C1160 FS_P_BLEED_0 TERM_P_R 0.11348f
C1161 PAD_P HS_N_1 0.48214f
C1162 a_41005_132385# ESD_RAIL 0.53823f
C1163 PULLUP_N_WELL FS_LOW_P 0.28858f
C1164 RX_P DIV_N 0.72665f
C1165 FS_HIGH_N TERM_VCM 0.07041f
C1166 FS_HIGH_P VCM_LOW_OK 0.02051f
C1167 PULLUP_P_BLEED_4 FS_LOW_N 0.02437f
C1168 PULLDOWN_P VCM_LOW_OK 0.04528f
C1169 FS_LOW_N FS_N_BLEED_5 0.084f
C1170 FS_P_GATE HS_N_5 1.04072f
C1171 DIV_LOW_N PULLUP_N_OUT 0.10124f
C1172 FS_P_BLEED_4 FS_P_GATE 0.27551f
C1173 HS_N_8 TERM_GATE_N_BLEED_1 0.0525f
C1174 HS_P_11 HS_N_4 0.06606f
C1175 FS_N_GATE HS_N_10 0.00893f
C1176 PULLUP_P_GATE PULLUP_P_OUT 19.8171f
C1177 HS_N HS_N_12 8.83112f
C1178 HS_N_1 PULLUP_P_OUT 0.03489f
C1179 HS_N_4 FS_LOW_N 0.08441f
C1180 PULLDOWN_P_R FS_P_BLEED_1 0.05445f
C1181 FS_N_BLEED_4 FS_N_WELL 0.01068f
C1182 PULLUP_P_BLEED_4 HS_N_5 0.0525f
C1183 DIV_ENABLE DIFF_ENABLE 5.44387f
C1184 FS_HIGH_N FS_LOW_P 0.11423f
C1185 HS_N_11 HS_N_10 0.13802p
C1186 PULLDOWN_P PULLUP_N_BLEED_4 0
C1187 TERM_OR_P_B HS_N_13 0.07271f
C1188 PULLUP_P_BLEED_5 HS_N_10 0.02441f
C1189 FS_P_BLEED_2 PULLUP_P_OUT 0.00257f
C1190 FS_P_BLEED_1 PULLDOWN_N_R 0.05445f
C1191 HS_N_1 HS_P_12 0.06335f
C1192 FS_P_WELL FS_N_OUT 0.93211f
C1193 FS_N_BLEED_4 PULLDOWN_N_R 0.04811f
C1194 HS_N_4 HS_P_0 0.03432f
C1195 HS_N_8 HS_N_2 0.00333f
C1196 HS_N_6 FS_HIGH_P 0.02404f
C1197 FS_N_BLEED_2 PULLUP_N_OUT 0.10124f
C1198 PULLDOWN_P HS_N_6 0.04428f
C1199 FS_P_BLEED_4 HS_N_4 0.06178f
C1200 m2_42279_124800# a_41005_132945# 0
C1201 DIV_N FS_HIGH_P 8.67054f
C1202 a_41005_134065# a_41005_133505# 0.0346f
C1203 HS_N_4 HS_N_5 0.12253p
C1204 PULLDOWN_P DIV_N 0.0465f
C1205 PULLDOWN_P_R PULLDOWN_N_R 33.296f
C1206 FS_P_GATE FS_P_WELL 0.26394p
C1207 TERM_ENABLE PULLUP_P_BLEED_3 0.05997f
C1208 DIFF_ENABLE PULLUP_N_BLEED_6 0.35616f
C1209 FS_N_WELL PULLDOWN_N_R 2.17394f
C1210 TERM_GATE_N_BLEED_0 TERM_GATE_N 4.39906f
C1211 TERM_GATE_N_BLEED_1 HS_N_7 0.0525f
C1212 PULLUP_N_BLEED_2 PULLUP_N_BLEED_0 0.00326f
C1213 TERM_N_R TERM_P_R 28.0337f
C1214 PULLUP_P_BLEED_3 HS_N_9 0.03489f
C1215 PAD_P FS_N_OUT 0.17964f
C1216 FS_P_OUT TERM_N_R 0.38548f
C1217 HS_N_8 HS_P_1 0.02866f
C1218 VDD FS_HIGH_P 0.65349f
C1219 DIV_LOW_N TERM_VCM 0.19527f
C1220 PULLDOWN_P VDD 1.70977f
C1221 PAD_N HS_N_2 1.16258f
C1222 TERM_OR_P_NS HS_P_11 0.04285f
C1223 HS_N_11 TERM_OR_N_S 0.02508f
C1224 DIV_LOW_P BYPASS_ENABLE 0
C1225 HS_N_4 FS_P_WELL 1.9794f
C1226 PULLUP_P_BLEED_3 PULLUP_P_BLEED_6 0
C1227 TERM_GATE_N HS_N_1 0.05139f
C1228 HS_N_7 HS_N_2 0.02926f
C1229 TERM_OR_N_NS TERM_P_R 0.21356f
C1230 TERM_P_R HS_P 0.07234f
C1231 a_41005_134065# ESD_RAIL 0.57348f
C1232 FS_P_OUT HS_P 0.68531f
C1233 FS_N_BLEED_4 BYPASS_ENABLE 0.00766f
C1234 FS_N_OUT PULLUP_P_OUT 0.06167f
C1235 PULLUP_P TERM_GATE_N_BLEED_1 0.09196f
C1236 FS_N_BLEED_0 PULLUP_N_OUT 0
C1237 HS_N_8 HS_PBIAS 3.45151f
C1238 HS_N_11 FS_P_CONTROL_S 0.03234f
C1239 FS_P_BLEED_1 BYPASS_ENABLE 0.00766f
C1240 TERM_OR_P_NS HS_P_0 0.07621f
C1241 FS_N_BLEED_2 TERM_VCM 0.02041f
C1242 PULLUP_P_GATE FS_P_BLEED_5 0.01836f
C1243 PULLUP_P_CONTROL_S FS_HIGH_P 0.12623f
C1244 HS_N VCM_LOW_OK 0.07865f
C1245 FS_LOW_N PULLUP_N_WELL 0.20869f
C1246 DIV_LOW_N FS_LOW_P 0.08856f
C1247 FS_P_OUT HS_P_13 0.1275f
C1248 FS_P_BLEED_5 HS_N_1 0.06178f
C1249 HS_P_13 TERM_P_R 0.08554f
C1250 TERM_OR_P_NS HS_N_5 0.00258f
C1251 HS_P_12 FS_N_OUT 0.12335f
C1252 PAD_N HS_P_1 0.56708f
C1253 HS_N_8 HS_P_5 0.05893f
C1254 TERM_GATE_P_BLEED_1 TERM_GATE_P_BLEED_2 1.09058f
C1255 PULLUP_P HS_N_2 0.02404f
C1256 PAD_P HS_N_4 0.06517f
C1257 FS_P_BLEED_5 FS_P_BLEED_2 0.12885f
C1258 FS_P_GATE PULLUP_P_OUT 1.53435f
C1259 FS_N_WELL BYPASS_ENABLE 0.05619f
C1260 TERM_ENABLE TERM_GATE_N_BLEED_0 0.04931f
C1261 HS_P_1 HS_N_7 0
C1262 HS_P_8 HS_P_9 30.3927f
C1263 FS_N_CONTROL_S FS_HIGH_N 7.6088f
C1264 PULLUP_N_BLEED_2 HS_P 0.00212f
C1265 FS_N_BLEED_2 FS_LOW_P 0.14463f
C1266 HS_N_9 TERM_GATE_N_BLEED_0 0.03489f
C1267 FS_P_GATE HS_P_12 0.00294f
C1268 TERM_N_R TERM_OR_N_B 5.91987f
C1269 FS_LOW_N FS_HIGH_N 0.08748f
C1270 PULLDOWN_P_R HS_P_6 0.02404f
C1271 TERM_ENABLE PULLUP_P_GATE 0.84363f
C1272 HS_N HS_N_6 7.99416f
C1273 TERM_ENABLE HS_N_1 0.04872f
C1274 HS_PBIAS HS_N_7 9.64698f
C1275 PULLUP_P_GATE HS_N_9 0.08704f
C1276 HS_N_4 PULLUP_P_OUT 0.03489f
C1277 HS_N DIV_N 0.0509f
C1278 HS_P_4 TERM_P_R 0.1254f
C1279 HS_P_6 PULLDOWN_N_R 0.02414f
C1280 TERM_OR_N_NS TERM_OR_N_B 1.66751f
C1281 HS_P TERM_OR_N_B 0
C1282 PAD_N HS_P_5 1.55482f
C1283 HS_N_12 FS_P_BLEED_6 0.06178f
C1284 TERM_GATE_N FS_N_OUT 0.05082f
C1285 TERM_N_R TERM_GATE_P 1.39719f
C1286 HS_N_4 HS_P_12 0.07181f
C1287 PULLUP_P_GATE PULLUP_P_BLEED_6 1.78667f
C1288 HS_N_7 HS_P_5 0.03489f
C1289 HS_PBIAS PULLUP_P 0.35017f
C1290 PULLUP_P_WELL PULLUP_N_OUT 0.6012f
C1291 HS_P_10 HS_P_2 0
C1292 HS_N VDD 2.60831f
C1293 FS_P_BLEED_5 FS_N_OUT 0.05624f
C1294 HS_P_1 HS_P_7 0.05962f
C1295 PULLUP_N_OUT HS_P_2 0.07964f
C1296 FS_N_BLEED_0 FS_LOW_P 0.79203f
C1297 HS_P TERM_GATE_P 0.22621f
C1298 HS_P_3 HS_N_2 0.02451f
C1299 FS_P_GATE FS_P_BLEED_5 0.31234f
C1300 HS_P_13 TERM_GATE_P 0.15775f
C1301 PULLUP_P_CONTROL_S HS_N 0.11565f
C1302 DIV_ENABLE TERM_GATE_N_BLEED_1 0
C1303 FS_P_BLEED_0 HS_N_11 0.06178f
C1304 PULLUP_N_OUT HS_N_3 0.00232f
C1305 HS_PBIAS HS_P_7 0.78499f
C1306 DIV_LOW_N FS_LOW_N 0.06178f
C1307 TERM_OR_P_NS PULLUP_P_OUT 0.1011f
C1308 PULLUP_P PULLUP_N_GATE 1.42018f
C1309 PULLUP_P_BLEED_1 PULLUP_N_OUT 0
C1310 TERM_ENABLE FS_N_OUT 0.47587f
C1311 HS_N_0 PULLUP_N_OUT 0.05062f
C1312 HS_N_4 TERM_GATE_N 0.04808f
C1313 FS_P_BLEED_4 FS_P_BLEED_3 2.07149f
C1314 FS_P_BLEED_3 HS_N_5 0.03351f
C1315 FS_N_BLEED_3 PULLUP_N_OUT 0.10124f
C1316 HS_P_3 HS_P_1 0.06154f
C1317 TERM_OR_P_NS HS_P_12 0.03931f
C1318 DIV_ENABLE HS_N_2 0.03089f
C1319 HS_N_13 FS_HIGH_P 0.02404f
C1320 FS_N_BLEED_2 FS_LOW_N 0
C1321 HS_P_7 HS_P_5 0.03078f
C1322 HS_N_4 FS_P_BLEED_5 0.06178f
C1323 DIV_LOW_N HS_N_5 0.06178f
C1324 PULLUP_P_WELL TERM_VCM 0.28547f
C1325 PULLDOWN_P HS_N_13 0.04428f
C1326 TERM_ENABLE FS_P_GATE 1.00704f
C1327 TERM_ENABLE PULLUP_P_BLEED_0 0.00606f
C1328 HS_P_4 TERM_GATE_P 0.15627f
C1329 FS_P_BLEED_6 VCM_LOW_OK 0.01451f
C1330 HS_P_2 TERM_VCM 0.09615f
C1331 FS_P_GATE HS_N_9 1.05196f
C1332 HS_PBIAS HS_P_3 6.23881f
C1333 PULLDOWN_P_R PULLUP_P_BLEED_3 0.05462f
C1334 HS_P_10 HS_N_10 0.09288f
C1335 HS_N TERM_OR_P_B 0.1311f
C1336 PULLUP_P_BLEED_4 HS_N_9 0.0525f
C1337 PULLUP_P_WELL FS_LOW_P 0.27223f
C1338 DIFF_ENABLE VDD 0.45362f
C1339 PULLUP_P_BLEED_3 PULLDOWN_N_R 0.05462f
C1340 TERM_ENABLE HS_N_4 0.04808f
C1341 HS_P_3 HS_P_5 0.03192f
C1342 HS_N_3 TERM_VCM 0.12325f
C1343 FS_N_GATE TERM_N_R 0.76877f
C1344 PULLUP_P_BLEED_1 TERM_VCM 0.01882f
C1345 HS_N_4 HS_N_9 0.04068f
C1346 PULLUP_P_BLEED_4 PULLUP_P_BLEED_6 0.00326f
C1347 HS_P_2 FS_LOW_P 0.04618f
C1348 HS_N_0 TERM_VCM 0.17286f
C1349 TERM_GATE_N_BLEED_1 HS_N_12 0.05263f
C1350 HS_N_6 FS_P_BLEED_6 0.06178f
C1351 FS_N_BLEED_3 TERM_VCM 0.13759f
C1352 FS_N_BLEED_0 FS_LOW_N 0.00206f
C1353 DIV_ENABLE HS_PBIAS 0.05806f
C1354 HS_N_11 TERM_N_R 0.05996f
C1355 FS_N_GATE HS_P 1.48197f
C1356 PULLUP_N_BLEED_1 PULLUP_N_BLEED_6 0.00257f
C1357 HS_N_3 FS_LOW_P 0.08505f
C1358 DIV_LOW_P HS_N_1 0.00376f
C1359 DIV_ENABLE HS_P_5 0.00252f
C1360 HS_P_10 HS_P_9 0.00887f
C1361 PULLUP_P_GATE FS_P_BLEED_1 0.00424f
C1362 HS_N_0 FS_LOW_P 0.08516f
C1363 TERM_OR_N_NS HS_N_11 0.03425f
C1364 HS_N_11 HS_P 0.77257f
C1365 HS_N_2 HS_N_12 0.02585f
C1366 PULLUP_P_BLEED_5 HS_P 0.10446f
C1367 PULLUP_N_OUT PULLUP_N 0.03945f
C1368 FS_P_BLEED_1 HS_N_1 0.03472f
C1369 FS_N_BLEED_3 FS_LOW_P 0.10387f
C1370 HS_PBIAS PULLUP_N_BLEED_6 0.04828f
C1371 PULLUP_P_BLEED_5 TERM_OR_N_NS 0
C1372 FS_P_BLEED_6 VDD 0.01345f
C1373 PULLUP_N_OUT HS_P_9 0.07928f
C1374 PULLUP_N_OUT TERM_OR_N_S 0.13603f
C1375 TERM_GATE_N_BLEED_0 PULLDOWN_N_R 0.04828f
C1376 PULLUP_P_BLEED_3 BYPASS_ENABLE 0.00766f
C1377 PULLUP_P_GATE PULLDOWN_P_R 0.39874f
C1378 FS_P_BLEED_1 FS_P_BLEED_2 1.41312f
C1379 FS_P_BLEED_3 PULLUP_P_OUT 0.00257f
C1380 TERM_VCM HS_N_10 0.12019f
C1381 DIV_ENABLE PULLUP_N_GATE 0
C1382 HS_P_13 HS_N_11 0.02487f
C1383 TERM_ENABLE TERM_OR_P_NS 0.1642f
C1384 PULLDOWN_P_R HS_N_1 0.02445f
C1385 HS_N HS_N_13 0.98202f
C1386 TERM_OR_P_NS HS_N_9 0.01002f
C1387 PULLUP_P_GATE PULLDOWN_N_R 0.23555f
C1388 HS_N_1 PULLDOWN_N_R 0.02404f
C1389 TERM_ENABLE PULLUP_N_WELL 0.52247f
C1390 HS_P_8 HS_P 3.0077f
C1391 PULLUP_N_GATE PULLUP_N_BLEED_6 6.07282f
C1392 HS_N_10 FS_LOW_P 0.08505f
C1393 PULLUP_P PULLUP_P_BLEED_2 0.14463f
C1394 HS_P_8 HS_P_13 0.05624f
C1395 HS_PBIAS HS_N_12 4.90809f
C1396 DIV_LOW_P FS_N_OUT 0.05525f
C1397 TERM_ENABLE FS_HIGH_N 0.05082f
C1398 HS_P_11 HS_P_2 0.00106f
C1399 HS_P_9 TERM_VCM 0.1405f
C1400 TERM_VCM TERM_OR_N_S 0
C1401 TERM_GATE_N_BLEED_0 BYPASS_ENABLE 0.00766f
C1402 RX_N BYPASS_ENABLE 7.32117f
C1403 HS_N_8 TERM_P_R 0.05914f
C1404 HS_N_8 FS_P_OUT 0.43367f
C1405 FS_P_BLEED_4 PULLUP_P_WELL 0
C1406 FS_P_BLEED_1 FS_N_OUT 0.36323f
C1407 HS_N_12 HS_P_5 0.03489f
C1408 HS_N_2 VCM_LOW_OK 0.05893f
C1409 PULLUP_P_WELL HS_N_5 0.11805f
C1410 HS_P_0 HS_P_2 0.00431f
C1411 TERM_GATE_N_BLEED_2 HS_N_11 0.02434f
C1412 a_41005_132385# a_41005_131545# 0
C1413 FS_LOW_N HS_N_3 0.08441f
C1414 TERM_GATE_N_BLEED_1 HS_N_6 0.0525f
C1415 TERM_P_R TERM_GATE_P_BLEED_1 0.00257f
C1416 DIV_LOW_N TERM_GATE_N 0.06956f
C1417 HS_P_8 HS_P_4 0.0312f
C1418 HS_P_2 HS_N_5 0.03089f
C1419 FS_P_GATE FS_P_BLEED_1 0.17756f
C1420 FS_P_BLEED_5 FS_P_BLEED_3 0.12036f
C1421 HS_P_9 FS_LOW_P 0.05657f
C1422 FS_N_WELL FS_N_OUT 0.1934p
C1423 TERM_GATE_N_BLEED_1 DIV_N 0
C1424 HS_N_0 FS_LOW_N 0.08452f
C1425 FS_N_BLEED_3 FS_LOW_N 0
C1426 FS_N_OUT PULLDOWN_N_R 0.56245f
C1427 TERM_GATE_P_BLEED_0 HS_P_1 0.05525f
C1428 HS_P_1 VCM_LOW_OK 0.03489f
C1429 PULLDOWN_P_R FS_P_GATE 1.57717f
C1430 HS_N_1 HS_P_6 0.06023f
C1431 FS_P_BLEED_4 HS_N_3 0.06178f
C1432 PAD_N FS_P_OUT 1.89403f
C1433 HS_N_0 HS_P_0 0.04061f
C1434 FS_N_BLEED_4 FS_N_BLEED_5 0.79478f
C1435 HS_N_5 HS_N_3 0.063f
C1436 HS_N_6 HS_N_2 0
C1437 FS_P_BLEED_4 HS_N_0 0.06178f
C1438 HS_N_7 TERM_P_R 0.10033f
C1439 FS_P_OUT HS_N_7 0.52477f
C1440 PULLUP_P_BLEED_0 PULLDOWN_P_R 0.01291f
C1441 FS_P_GATE PULLDOWN_N_R 1.47723f
C1442 HS_N_0 HS_N_5 0.04157f
C1443 HS_N_2 DIV_N 0.03462f
C1444 PULLDOWN_P_R PULLUP_P_BLEED_4 0.09196f
C1445 HS_N_4 FS_P_BLEED_1 0.03472f
C1446 PULLUP_N_OUT FS_P_BLEED_0 0.11535f
C1447 TERM_GATE_P_BLEED_2 VCM_LOW_OK 0.01429f
C1448 HS_N_8 TERM_OR_N_B 0
C1449 PULLUP_P_BLEED_0 PULLDOWN_N_R 0.00171f
C1450 TERM_GATE_P_BLEED_0 TERM_GATE_P_BLEED_2 0.10759f
C1451 a_53878_132665# a_53878_133225# 0.0346f
C1452 HS_PBIAS VCM_LOW_OK 0.42204f
C1453 HS_N FS_HIGH_P 0.02498f
C1454 TERM_ENABLE DIV_LOW_N 0.07174f
C1455 PULLUP_P_BLEED_4 PULLDOWN_N_R 0.09196f
C1456 FS_P_BLEED_3 HS_N_9 0.04642f
C1457 FS_N_GATE FS_N_BLEED_1 0.29846f
C1458 HS_P_11 HS_N_10 0.00351f
C1459 PULLUP_P TERM_P_R 0.1121f
C1460 FS_LOW_N HS_N_10 0.08441f
C1461 PULLDOWN_P_R HS_N_4 0.02404f
C1462 HS_P_1 HS_N_6 0.03099f
C1463 HS_N_2 VDD 5.27157f
C1464 DIV_LOW_N HS_N_9 0.06178f
C1465 TERM_GATE_P_BLEED_0 HS_P_5 0.0244f
C1466 HS_N_3 FS_P_WELL 1.96364f
C1467 HS_P_5 VCM_LOW_OK 0.03489f
C1468 HS_P_0 HS_N_10 0.06989f
C1469 HS_N_4 PULLDOWN_N_R 0.06159f
C1470 HS_N_0 FS_P_WELL 2.61482f
C1471 PAD_P HS_P_2 1.20139f
C1472 TERM_ENABLE FS_N_BLEED_2 0.08954f
C1473 HS_N_8 TERM_GATE_P 0.12805f
C1474 DIV_P TERM_P_R 0.02242f
C1475 FS_P_OUT DIV_P 0.01279f
C1476 HS_N_13 FS_P_BLEED_6 0.06178f
C1477 HS_N_5 HS_N_10 0
C1478 FS_N_BLEED_6 HS_P 0.11073f
C1479 FS_P_BLEED_4 HS_N_10 0.06178f
C1480 HS_PBIAS HS_N_6 7.23511f
C1481 PULLUP_P_CONTROL_S HS_N_2 0.04855f
C1482 PULLUP_P_WELL PULLUP_P_OUT 29.1254f
C1483 HS_PBIAS DIV_N 0.14108f
C1484 HS_P_1 VDD 5.54122f
C1485 PAD_P HS_N_3 0.09104f
C1486 HS_P_7 TERM_P_R 0.08343f
C1487 TERM_GATE_P_BLEED_1 TERM_GATE_P 0.37616f
C1488 TERM_VCM FS_P_BLEED_0 0.09235f
C1489 HS_P_6 FS_N_OUT 0.06167f
C1490 PULLUP_P PULLUP_N_BLEED_3 0.05126f
C1491 HS_P_10 TERM_N_R 0.05037f
C1492 PAD_P HS_N_0 0.14558f
C1493 HS_P_2 PULLUP_P_OUT 0.06773f
C1494 HS_N_6 HS_P_5 0.1437f
C1495 HS_P_11 HS_P_9 0.00817f
C1496 FS_LOW_N TERM_OR_N_S 0.4405f
C1497 PULLUP_N_GATE PULLUP_N_BLEED_4 0.20501f
C1498 HS_P_5 DIV_N 0.01203f
C1499 PULLUP_N_OUT TERM_N_R 0.30705f
C1500 VDD TERM_GATE_P_BLEED_2 0.084f
C1501 HS_PBIAS VDD 83.74921f
C1502 HS_P_2 HS_P_12 0.00206f
C1503 FS_N_BLEED_4 PULLUP_N_WELL 0.01353f
C1504 TERM_OR_P_NS PULLDOWN_P_R 0.05654f
C1505 PULLUP_P TERM_OR_N_B 0.09232f
C1506 FS_P_WELL HS_N_10 2.06442f
C1507 HS_N_3 PULLUP_P_OUT 0.03489f
C1508 HS_N_7 TERM_GATE_P 0.12198f
C1509 TERM_OR_P_NS PULLDOWN_N_R 0.04591f
C1510 HS_P_10 HS_P 2.44809f
C1511 PULLUP_P_GATE PULLUP_P_BLEED_3 0.23044f
C1512 HS_N_0 PULLUP_P_OUT 0.03489f
C1513 HS_N_5 TERM_OR_N_S 0.02662f
C1514 DIFF_ENABLE FS_HIGH_P 0.2074f
C1515 HS_P_3 TERM_P_R 0.12136f
C1516 TERM_OR_P_B HS_N_2 0.07258f
C1517 HS_P_3 FS_P_OUT 0.09146f
C1518 PULLDOWN_P DIFF_ENABLE 0.21707f
C1519 HS_P_5 VDD 4.75167f
C1520 PULLUP_P_BLEED_3 HS_N_1 0.03489f
C1521 TERM_OR_N_NS PULLUP_N_OUT 0.05397f
C1522 PULLUP_N_OUT HS_P 0.09327f
C1523 HS_N_5 FS_P_CONTROL_S 0.03226f
C1524 HS_N_3 HS_P_12 0.03489f
C1525 FS_N_BLEED_4 FS_HIGH_N 0.16623f
C1526 PULLUP_N_WELL PULLDOWN_N_R 0.304f
C1527 PULLUP_P_CONTROL_S HS_PBIAS 0.07486f
C1528 HS_P_10 HS_P_13 0.09466f
C1529 HS_N_4 HS_P_6 0.0599f
C1530 HS_N_0 HS_P_12 0.07547f
C1531 PULLUP_N_GATE VDD 11.92f
C1532 PAD_P HS_N_10 0.11949f
C1533 PULLUP_N_OUT HS_P_13 0.02868f
C1534 TERM_OR_P_B HS_P_1 0.08191f
C1535 FS_N_WELL FS_HIGH_N 2.50709f
C1536 DIV_ENABLE TERM_P_R 0.05603f
C1537 FS_P_BLEED_5 PULLUP_P_WELL 0.00636f
C1538 DIV_ENABLE FS_P_OUT 0.0629f
C1539 PULLUP_N_BLEED_0 FS_LOW_P 0.05872f
C1540 DIV_P TERM_GATE_P 0.02274f
C1541 FS_HIGH_N PULLDOWN_N_R 0.03743f
C1542 TERM_VCM TERM_N_R 17.5283f
C1543 HS_N_8 FS_N_GATE 0.00226f
C1544 FS_P_WELL FS_P_CONTROL_S 0.18587f
C1545 HS_N_10 PULLUP_P_OUT 0.03489f
C1546 HS_P_10 HS_P_4 0
C1547 HS_P_7 TERM_GATE_P 0.15508f
C1548 TERM_OR_P_B TERM_GATE_P_BLEED_2 0.00349f
C1549 HS_P_12 HS_N_10 0.07709f
C1550 TERM_GATE_N_BLEED_0 HS_N_1 0.03489f
C1551 TERM_GATE_N_BLEED_1 HS_N_13 0.0525f
C1552 TERM_GATE_N HS_N_3 0.04808f
C1553 HS_P_4 PULLUP_N_OUT 0.0863f
C1554 PULLUP_P_BLEED_5 HS_N_8 0.04243f
C1555 HS_N_8 HS_N_11 0.03489f
C1556 TERM_P_R PULLUP_N_BLEED_6 0.04797f
C1557 TERM_OR_N_NS TERM_VCM 0.03439f
C1558 TERM_VCM HS_P 0.21204f
C1559 HS_N_0 TERM_GATE_N 0.05542f
C1560 PULLUP_N_WELL BYPASS_ENABLE 0.01588f
C1561 PAD_P HS_P_9 1.35439f
C1562 TERM_ENABLE PULLUP_P_WELL 2.34229f
C1563 TERM_N_R FS_LOW_P 0.16749f
C1564 TERM_OR_P_NS HS_P_6 0.02846f
C1565 FS_P_BLEED_5 HS_N_3 0.06178f
C1566 PULLUP_P_BLEED_3 FS_N_OUT 0.06167f
C1567 PULLDOWN_N PULLDOWN_N_R 2.99559f
C1568 TERM_OR_P_B HS_P_5 0.10156f
C1569 PULLUP_P_WELL HS_N_9 0.14182f
C1570 PULLUP_P_GATE HS_N_1 0.08375f
C1571 HS_N_0 FS_P_BLEED_5 0.06178f
C1572 HS_N_2 HS_N_13 0.12568p
C1573 TERM_ENABLE HS_P_2 0.06392f
C1574 TERM_VCM HS_P_13 0.09664f
C1575 TERM_GATE_N_BLEED_2 PULLUP_N_OUT 0.09196f
C1576 PULLUP_P_GATE FS_P_BLEED_2 0
C1577 PULLUP_P_BLEED_2 VCM_LOW_OK 0.15227f
C1578 HS_N_1 FS_P_BLEED_2 0
C1579 HS_N_9 HS_P_2 0.03089f
C1580 HS_P_8 HS_N_8 0.09066f
C1581 TERM_OR_N_NS FS_LOW_P 0.12663f
C1582 HS_P FS_LOW_P 0.09863f
C1583 HS_P_3 TERM_GATE_P 0.15659f
C1584 PULLUP_N_BLEED_2 PULLUP_N_BLEED_6 0.00257f
C1585 HS_P_9 PULLUP_P_OUT 0.06897f
C1586 PULLUP_P_BLEED_0 PULLUP_P_BLEED_3 0.0078f
C1587 HS_N DIFF_ENABLE 0.3376f
C1588 FS_HIGH_N BYPASS_ENABLE 0
C1589 PULLUP_N_WELL PULLUP_N_CONTROL_S 0.11761f
C1590 PAD_N HS_N_11 1.22201f
C1591 PULLUP_N_BLEED_3 PULLUP_N_BLEED_6 0.0078f
C1592 PULLUP_P_BLEED_3 PULLUP_P_BLEED_4 6.29036f
C1593 FS_N_BLEED_2 FS_N_BLEED_4 0.00855f
C1594 TERM_ENABLE HS_N_3 0.04808f
C1595 HS_P_13 FS_LOW_P 0.04601f
C1596 TERM_ENABLE PULLUP_P_BLEED_1 0.07608f
C1597 TERM_GATE_N HS_N_10 0.04869f
C1598 FS_P_OUT HS_N_12 0.43801f
C1599 HS_N_7 HS_N_11 0.02985f
C1600 HS_N_12 TERM_P_R 0.0597f
C1601 PULLUP_P_BLEED_5 HS_N_7 0.03702f
C1602 TERM_ENABLE HS_N_0 0.10582f
C1603 DIV_LOW_N PULLDOWN_N_R 0.08856f
C1604 HS_N_9 HS_N_3 0.03256f
C1605 TERM_ENABLE FS_N_BLEED_3 0.11535f
C1606 HS_N_5 FS_P_BLEED_0 0.06178f
C1607 a_53878_132105# a_53878_132665# 0.0346f
C1608 HS_P_4 TERM_VCM 0.12461f
C1609 PULLUP_P FS_N_GATE 1.02581f
C1610 HS_N_0 HS_N_9 0.04157f
C1611 PULLUP_P_BLEED_3 HS_N_4 0.03489f
C1612 FS_P_BLEED_5 HS_N_10 0.06178f
C1613 FS_N_BLEED_2 FS_N_WELL 0.35588f
C1614 DIV_ENABLE TERM_GATE_P 0.00432f
C1615 TERM_GATE_N_BLEED_0 FS_N_OUT 0.06167f
C1616 PAD_N HS_P_8 0.85512f
C1617 HS_PBIAS HS_N_13 7.29451f
C1618 RX_N FS_N_OUT 0.01566f
C1619 FS_LOW_N PULLUP_N_BLEED_0 0.08389f
C1620 FS_N_BLEED_2 PULLDOWN_N_R 0.08856f
C1621 PULLUP_P HS_N_11 0.02473f
C1622 PULLUP_P_BLEED_5 PULLUP_P 0.15607f
C1623 TERM_GATE_N_BLEED_2 TERM_VCM 0.02153f
C1624 HS_P_4 FS_LOW_P 0.04599f
C1625 PULLUP_P_GATE FS_N_OUT 0.1125f
C1626 HS_N_1 FS_N_OUT 0.06167f
C1627 a_53878_134345# a_53878_133785# 0.0346f
C1628 HS_N_13 HS_P_5 0.03489f
C1629 HS_N FS_P_BLEED_6 0.08043f
C1630 FS_P_WELL FS_P_BLEED_0 6.36796f
C1631 PULLUP_P_BLEED_2 VDD 0.57693f
C1632 TERM_ENABLE HS_N_10 0.04862f
C1633 FS_N_CONTROL_S TERM_N_R 0.12536f
C1634 TERM_GATE_N TERM_OR_N_S 0.0189f
C1635 FS_N_BLEED_0 FS_N_BLEED_4 0.00763f
C1636 FS_N_BLEED_1 PULLUP_N_OUT 0.05216f
C1637 FS_N_OUT FS_P_BLEED_2 0.15927f
C1638 HS_P_11 TERM_N_R 0.05722f
C1639 PULLUP_P_GATE FS_P_GATE 0.53486f
C1640 a_53878_133225# a_53878_133785# 0.0346f
C1641 HS_N_9 HS_N_10 0.03655f
C1642 FS_LOW_N TERM_N_R 0.11177f
C1643 TERM_GATE_N_BLEED_1 FS_HIGH_P 0.01347f
C1644 DIV_LOW_N BYPASS_ENABLE 0.00106f
C1645 FS_P_GATE HS_N_1 1.0435f
C1646 PULLUP_P_GATE PULLUP_P_BLEED_0 0.16374f
C1647 PULLDOWN_P TERM_GATE_N_BLEED_1 0.07928f
C1648 HS_N_4 TERM_GATE_N_BLEED_0 0.03489f
C1649 PULLUP_P_GATE PULLUP_P_BLEED_4 0.10639f
C1650 FS_P_GATE FS_P_BLEED_2 0.11441f
C1651 FS_N_CONTROL_S HS_P 0.09439f
C1652 FS_N_BLEED_0 FS_N_WELL 2.72415f
C1653 PULLUP_P_BLEED_4 HS_N_1 0.05286f
C1654 FS_P_OUT VCM_LOW_OK 0.37711f
C1655 HS_P_11 HS_P 5.65023f
C1656 TERM_GATE_P_BLEED_0 TERM_P_R 0.00257f
C1657 TERM_P_R VCM_LOW_OK 0.39366f
C1658 HS_N_5 TERM_N_R 0.05893f
C1659 HS_N_2 FS_HIGH_P 0.02404f
C1660 FS_N_BLEED_0 PULLDOWN_N_R 0.05188f
C1661 TERM_OR_N_NS FS_LOW_N 3.61751f
C1662 FS_LOW_N HS_P 0.08532f
C1663 PULLUP_P_GATE HS_N_4 0.08296f
C1664 HS_N_12 TERM_GATE_P 0.10814f
C1665 HS_P_8 HS_P_7 30.9838f
C1666 HS_N_4 HS_N_1 0
C1667 HS_P_11 HS_P_13 0.08851f
C1668 HS_P_0 HS_P 17.7665f
C1669 TERM_ENABLE PULLUP_N 0.01513f
C1670 TERM_ENABLE HS_P_9 0.07435f
C1671 TERM_ENABLE TERM_OR_N_S 5.34861f
C1672 HS_P_3 HS_N_11 0.02508f
C1673 FS_P_BLEED_4 HS_P 0.06337f
C1674 TERM_OR_N_NS HS_N_5 0.03425f
C1675 HS_N_5 HS_P 0.87187f
C1676 HS_N_9 TERM_OR_N_S 0.03405f
C1677 PULLUP_N_BLEED_4 TERM_P_R 0.04588f
C1678 FS_P_BLEED_0 PULLUP_P_OUT 0.11038f
C1679 HS_N_9 HS_P_9 0.06704f
C1680 HS_P_0 HS_P_13 0.01899f
C1681 FS_P_OUT HS_N_6 0.43331f
C1682 HS_N_6 TERM_P_R 0.0959f
C1683 HS_N_9 FS_P_CONTROL_S 0.03242f
C1684 FS_P_WELL TERM_N_R 1.63349f
C1685 DIV_ENABLE FS_N_GATE 0.004f
C1686 PULLDOWN_P PULLUP_N_BLEED_1 0.06517f
C1687 DIV_N TERM_P_R 0
C1688 FS_P_OUT DIV_N 0.05123f
C1689 HS_N_5 HS_P_13 0.05493f
C1690 FS_P_BLEED_1 PULLUP_P_WELL 0.00137f
C1691 HS_P_8 HS_P_3 0.03109f
C1692 HS_P_11 HS_P_4 0
C1693 FS_P_GATE FS_N_OUT 0.35576f
C1694 DIV_ENABLE HS_N_11 0.03161f
C1695 TERM_OR_N_B VCM_LOW_OK 2.86687f
C1696 HS_PBIAS FS_HIGH_P 0.07608f
C1697 FS_N_BLEED_1 FS_LOW_P 0.23767f
C1698 PULLUP_N_BLEED_2 PULLUP_N_BLEED_4 0.00234f
C1699 HS_PBIAS PULLDOWN_P 0.44043f
C1700 FS_P_WELL HS_P 2.08315f
C1701 PULLUP_P_BLEED_4 FS_N_OUT 0.06408f
C1702 PULLDOWN_P_R PULLUP_P_WELL 0.59282f
C1703 FS_P_OUT VDD 10.8417f
C1704 PULLUP_N_BLEED_3 PULLUP_N_BLEED_4 1.53214f
C1705 TERM_P_R VDD 6.53315f
C1706 HS_P_4 HS_P_0 0.00219f
C1707 PAD_P TERM_N_R 0.19266f
C1708 PULLUP_P_WELL PULLDOWN_N_R 0.39593f
C1709 PULLDOWN_P_R HS_P_2 0.07466f
C1710 HS_N_0 DIV_LOW_P 0.00585f
C1711 FS_P_WELL HS_P_13 0.19945f
C1712 HS_N TERM_GATE_N_BLEED_1 0.10264f
C1713 HS_P_4 HS_N_5 0.13307f
C1714 HS_P_10 HS_N_8 0.0286f
C1715 FS_P_BLEED_1 HS_N_3 0.03472f
C1716 HS_P_2 PULLDOWN_N_R 0.07217f
C1717 TERM_GATE_P VCM_LOW_OK 0.20188f
C1718 PULLUP_N_GATE FS_HIGH_P 0.01763f
C1719 HS_N_0 FS_P_BLEED_1 0.03472f
C1720 PAD_P HS_P 39.8004f
C1721 FS_N_BLEED_3 FS_N_BLEED_4 9.3821f
C1722 HS_N_8 PULLUP_N_OUT 0.01067f
C1723 TERM_GATE_P_BLEED_0 TERM_GATE_P 4.84915f
C1724 PULLDOWN_P PULLUP_N_GATE 0.18497f
C1725 HS_N HS_N_2 6.83901f
C1726 HS_N_4 FS_P_GATE 1.03504f
C1727 PULLDOWN_P_R HS_N_3 0.02404f
C1728 PULLUP_P_OUT TERM_N_R 0.09296f
C1729 TERM_GATE_N_BLEED_2 HS_N_5 0.03089f
C1730 PULLDOWN_P_R HS_N_0 0.02508f
C1731 PAD_P HS_P_13 1.35247f
C1732 HS_N_4 PULLUP_P_BLEED_4 0.0525f
C1733 HS_N_3 PULLDOWN_N_R 0.02404f
C1734 PULLUP_N_OUT TERM_GATE_P_BLEED_1 0.05318f
C1735 FS_N_GATE HS_N_12 0.01973f
C1736 a_53878_132665# ESD_RAIL 0.53916f
C1737 FS_N_BLEED_3 FS_N_WELL 0.1181f
C1738 HS_N_0 PULLDOWN_N_R 0.06832f
C1739 PULLUP_P_OUT HS_P 0.03526f
C1740 PAD_N HS_P_10 0.42477f
C1741 DIV_LOW_P HS_N_10 0.00259f
C1742 FS_N_BLEED_3 PULLDOWN_N_R 0.08856f
C1743 HS_N_6 TERM_GATE_P 0.11785f
C1744 VDD TERM_OR_N_B 10.4444f
C1745 HS_P_10 HS_N_7 0
C1746 HS_N HS_P_1 0.75007f
C1747 PULLUP_P_WELL BYPASS_ENABLE 0.00823f
C1748 PULLUP_P_BLEED_5 HS_N_12 0.02427f
C1749 HS_N_12 HS_N_11 0.1373p
C1750 PAD_N PULLUP_N_OUT 1.29311f
C1751 FS_P_BLEED_1 HS_N_10 0.03472f
C1752 DIV_N TERM_GATE_P 0.00178f
C1753 TERM_ENABLE FS_P_BLEED_0 0.11038f
C1754 HS_N PULLUP_N_BLEED_1 0.06387f
C1755 HS_P_12 HS_P 3.63983f
C1756 PULLUP_N_BLEED_5 PULLUP_N 0.06639f
C1757 PULLUP_N_OUT HS_N_7 0.05812f
C1758 TERM_OR_P_B TERM_P_R 0.76857f
C1759 TERM_OR_P_B FS_P_OUT 0.16122f
C1760 PAD_P HS_P_4 1.13663f
C1761 HS_N_9 FS_P_BLEED_0 0.06178f
C1762 HS_P_13 HS_P_12 47.0352f
C1763 PULLDOWN_P_R HS_N_10 0.02436f
C1764 HS_N_8 TERM_VCM 0.13427f
C1765 HS_N HS_PBIAS 0.39831f
C1766 FS_N_WELL HS_N_10 0.00889f
C1767 FS_N_BLEED_1 FS_LOW_N 0.00106f
C1768 VDD TERM_GATE_P 7.09843f
C1769 TERM_GATE_N TERM_N_R 26.1022f
C1770 HS_N_10 PULLDOWN_N_R 0.02404f
C1771 TERM_P_R TERM_OR_P_S 2.01371f
C1772 HS_P_2 HS_P_6 0.06956f
C1773 PULLUP_P PULLUP_N_OUT 29.6142f
C1774 PULLUP_P_GATE FS_P_BLEED_3 0
C1775 HS_N HS_P_5 0.39228f
C1776 HS_P_4 PULLUP_P_OUT 0.05519f
C1777 FS_P_BLEED_3 HS_N_1 0.02938f
C1778 HS_N_8 FS_LOW_P 0.21311f
C1779 HS_N PULLUP_N_GATE 0.16548f
C1780 TERM_GATE_N HS_P 0.05324f
C1781 FS_P_BLEED_3 FS_P_BLEED_2 0.53961f
C1782 FS_HIGH_N FS_N_OUT 0.03054f
C1783 HS_N_3 HS_P_6 0.05828f
C1784 HS_P_4 HS_P_12 0
C1785 DIV_LOW_N HS_N_1 0.06178f
C1786 HS_P_10 HS_P_7 0.10683f
C1787 TERM_OR_P_NS HS_N_4 0.00196f
C1788 FS_P_BLEED_1 FS_P_CONTROL_S 0
C1789 PAD_N TERM_VCM 0.001f
C1790 HS_N_0 HS_P_6 0.06114f
C1791 PULLUP_N_WELL FS_N_BLEED_5 0
C1792 HS_N_7 TERM_VCM 0.16639f
C1793 PULLDOWN_P_R HS_P_9 0.07466f
C1794 PULLUP_N_OUT HS_P_7 0.02846f
C1795 FS_P_BLEED_5 HS_P 0.06178f
C1796 PULLUP_P_BLEED_5 VCM_LOW_OK 0
C1797 HS_N_11 VCM_LOW_OK 0.05893f
C1798 PULLUP_N PULLDOWN_N_R 0.00106f
C1799 PULLDOWN_N_R TERM_OR_N_S 0.08196f
C1800 HS_P_9 PULLDOWN_N_R 4.1634f
C1801 TERM_ENABLE TERM_N_R 0.4835f
C1802 HS_N_13 TERM_P_R 0.0965f
C1803 FS_P_OUT HS_N_13 0.52823f
C1804 HS_N_9 TERM_N_R 0.0592f
C1805 PAD_N ESD_RAIL 22.6825f
C1806 FS_HIGH_N FS_N_BLEED_5 0.00933f
C1807 PULLUP_P TERM_VCM 0.21883f
C1808 HS_N_7 FS_LOW_P 0.0855f
C1809 HS_P_10 HS_P_3 0.02866f
C1810 TERM_ENABLE HS_P 0.05441f
C1811 HS_N_2 FS_P_BLEED_6 0.06178f
C1812 TERM_OR_P_B TERM_GATE_P 12.9405f
C1813 HS_PBIAS DIFF_ENABLE 0.27859f
C1814 TERM_ENABLE TERM_OR_N_NS 0.10081f
C1815 TERM_GATE_P_BLEED_0 HS_P_8 0.0271f
C1816 HS_P_8 VCM_LOW_OK 0.03489f
C1817 HS_N_6 HS_N_11 0
C1818 HS_P_6 HS_N_10 0.0597f
C1819 DIV_P TERM_VCM 0.13218f
C1820 HS_P_3 PULLUP_N_OUT 0.08633f
C1821 PULLUP_P_BLEED_5 HS_N_6 0.03334f
C1822 TERM_OR_N_NS HS_N_9 0.03425f
C1823 HS_N_9 HS_P 0.12097p
C1824 TERM_ENABLE HS_P_13 0.02404f
C1825 FS_P_BLEED_3 FS_N_OUT 0.08101f
C1826 HS_N_11 DIV_N 0.03462f
C1827 HS_N_9 HS_P_13 0.05493f
C1828 PULLUP_P FS_LOW_P 0.10849f
C1829 PULLUP_P_BLEED_6 HS_P 0.00212f
C1830 FS_N_GATE VDD 23.571f
C1831 TERM_VCM HS_P_7 0.11665f
C1832 PULLUP_P_BLEED_3 PULLUP_P_WELL 0.00303f
C1833 DIV_LOW_N FS_N_OUT 0.11535f
C1834 PULLUP_P_BLEED_6 TERM_OR_N_NS 0
C1835 TERM_GATE_N_BLEED_2 TERM_GATE_N 0.42751f
C1836 FS_P_GATE FS_P_BLEED_3 0.27756f
C1837 DIV_P FS_LOW_P 2.36145f
C1838 PULLUP_N_GATE DIFF_ENABLE 0.07144f
C1839 DIV_ENABLE PULLUP_N_OUT 0.05062f
C1840 HS_N_8 FS_LOW_N 0.1267f
C1841 HS_P_11 HS_N_8 0.02857f
C1842 HS_N_11 VDD 6.59331f
C1843 RX_P FS_P_OUT 0.01238f
C1844 HS_PBIAS FS_P_BLEED_6 0.08856f
C1845 HS_P_7 FS_LOW_P 0.04566f
C1846 TERM_ENABLE HS_P_4 0.07923f
C1847 HS_N_8 HS_P_0 0.03523f
C1848 HS_P_9 HS_P_6 0.00106f
C1849 FS_P_BLEED_4 HS_N_8 0.06266f
C1850 HS_P_4 HS_N_9 0.03089f
C1851 PULLUP_P_BLEED_3 HS_N_3 0.03489f
C1852 PULLUP_N PULLUP_N_CONTROL_S 1.30292f
C1853 HS_N_4 FS_P_BLEED_3 0.03227f
C1854 PULLUP_P_BLEED_3 PULLUP_P_BLEED_1 0.00855f
C1855 HS_P_3 TERM_VCM 0.12019f
C1856 FS_P_BLEED_1 FS_P_BLEED_0 8.76361f
C1857 HS_N_8 HS_N_5 0.04101f
C1858 PULLUP_P_BLEED_3 HS_N_0 0.03489f
C1859 PULLUP_P_CONTROL_S HS_N_11 0.04911f
C1860 HS_P_8 VDD 4.99906f
C1861 HS_N_4 DIV_LOW_N 0.06178f
C1862 FS_HIGH_N PULLUP_N_WELL 0.30788f
C1863 HS_N_13 TERM_GATE_P 0.1076f
C1864 TERM_ENABLE TERM_GATE_N_BLEED_2 0.07928f
C1865 PAD_N HS_P_11 1.42473f
C1866 PULLDOWN_P_R FS_P_BLEED_0 0.10124f
C1867 a_44789_117064# ESD_RAIL 13.9519f
C1868 HS_P_11 HS_N_7 0
C1869 TERM_GATE_N_BLEED_2 HS_N_9 0.04943f
C1870 FS_LOW_N HS_N_7 0.08486f
C1871 HS_P_3 FS_LOW_P 0.04607f
C1872 PULLUP_P_GATE PULLUP_P_WELL 35.6995f
C1873 PAD_N HS_P_0 0.38312f
C1874 FS_P_BLEED_0 PULLDOWN_N_R 0.10124f
C1875 FS_P_OUT FS_HIGH_P 0.13265f
C1876 PULLDOWN_P TERM_P_R 0.04141f
C1877 DIV_ENABLE TERM_VCM 0.20793f
C1878 PULLUP_N_BLEED_5 TERM_N_R 0.11444f
C1879 HS_N_8 FS_P_WELL 1.99903f
C1880 HS_P_10 HS_N_12 0.04371f
C1881 PULLUP_P_WELL HS_N_1 0.1499f
C1882 HS_P_0 HS_N_7 0
C1883 PAD_N HS_N_5 1.1645f
C1884 FS_N_CONTROL_S PULLUP_P 0.10706f
C1885 TERM_GATE_N_BLEED_1 HS_N_2 0.0525f
C1886 HS_P_2 HS_N_1 0.00649f
C1887 HS_N_7 HS_N_5 0.07689f
C1888 PULLUP_P_BLEED_3 HS_N_10 0.03489f
C1889 PULLUP_N_OUT HS_N_12 0.04377f
C1890 FS_P_BLEED_4 HS_N_7 0.06246f
C1891 TERM_GATE_N_BLEED_0 HS_N_3 0.03489f
C1892 PULLUP_P_WELL FS_P_BLEED_2 0
C1893 TERM_OR_P_B HS_N_11 0.07338f
C1894 PULLUP_P FS_LOW_N 0.06432f
C1895 HS_N_0 TERM_GATE_N_BLEED_0 0.03489f
C1896 RX_N HS_N_0 0.00305f
C1897 TERM_VCM PULLUP_N_BLEED_6 0.04263f
C1898 DIV_ENABLE FS_LOW_P 0.10881f
C1899 PAD_P HS_N_8 0.43522f
C1900 PULLDOWN_P PULLUP_N_BLEED_2 0.08014f
C1901 PULLUP_P_GATE HS_N_3 0.08296f
C1902 PULLUP_P_GATE PULLUP_P_BLEED_1 0.19163f
C1903 a_53878_133785# ESD_RAIL 0.53942f
C1904 PULLUP_N_BLEED_0 PULLDOWN_N_R 0.07928f
C1905 PULLDOWN_P PULLUP_N_BLEED_3 0.00326f
C1906 FS_P_BLEED_1 TERM_N_R 0.06105f
C1907 FS_N_BLEED_4 TERM_N_R 0.06105f
C1908 HS_N_3 HS_N_1 0.03945f
C1909 PULLUP_P HS_N_5 0.0678f
C1910 PULLUP_P_GATE HS_N_0 0.08394f
C1911 TERM_OR_P_B HS_P_8 0.10057f
C1912 HS_N_0 HS_N_1 0.12498p
C1913 HS_P_11 HS_P_7 0.0963f
C1914 HS_N_7 FS_P_WELL 1.98759f
C1915 TERM_ENABLE FS_N_BLEED_1 0.01168f
C1916 PULLDOWN_P TERM_OR_N_B 0.04844f
C1917 FS_LOW_P PULLUP_N_BLEED_6 0.06116f
C1918 HS_N_0 FS_P_BLEED_2 0
C1919 FS_N_WELL TERM_N_R 1.45715f
C1920 HS_N_8 PULLUP_P_OUT 0.0351f
C1921 FS_P_BLEED_1 HS_P 0.03472f
C1922 HS_P_0 HS_P_7 0.00469f
C1923 FS_N_BLEED_4 HS_P 0.04811f
C1924 HS_PBIAS TERM_GATE_N_BLEED_1 0.07928f
C1925 TERM_GATE_N_BLEED_0 HS_N_10 0.03489f
C1926 FS_N_BLEED_2 PULLUP_N_WELL 0
C1927 HS_P_1 HS_N_2 0.09798f
C1928 TERM_N_R PULLDOWN_N_R 0.12913f
C1929 PULLUP_P_WELL FS_N_OUT 0.13784f
C1930 PAD_P PAD_N 58.971f
C1931 HS_N_12 TERM_VCM 0.12019f
C1932 FS_N_GATE HS_N_13 0.19342f
C1933 HS_N_8 HS_P_12 0.06335f
C1934 HS_P_10 VCM_LOW_OK 0.09044f
C1935 TERM_GATE_P_BLEED_0 HS_P_10 0.03777f
C1936 PULLDOWN_P_R HS_P 0.03048f
C1937 PULLUP_P_OUT TERM_GATE_P_BLEED_1 0.14929f
C1938 PAD_P HS_N_7 0.03829f
C1939 a_41005_131825# ESD_RAIL 0.53823f
C1940 PULLUP_P_GATE HS_N_10 0.08357f
C1941 FS_N_WELL HS_P 2.92153f
C1942 HS_P_11 HS_P_3 0.02877f
C1943 PULLUP_N_OUT VCM_LOW_OK 0.20396f
C1944 HS_PBIAS HS_N_2 1.31428f
C1945 FS_P_GATE PULLUP_P_WELL 0
C1946 TERM_OR_N_NS PULLDOWN_N_R 0.04764f
C1947 TERM_GATE_P_BLEED_0 PULLUP_N_OUT 0.10679f
C1948 HS_N_1 HS_N_10 0.12635p
C1949 PULLDOWN_N_R HS_P 0.08383f
C1950 HS_N_13 HS_N_11 0.09269f
C1951 HS_N TERM_P_R 0.11349f
C1952 HS_N FS_P_OUT 20.4712f
C1953 PULLUP_P_BLEED_5 HS_N_13 0.02404f
C1954 PULLUP_P_BLEED_0 PULLUP_P_WELL 1.08596f
C1955 FS_N_BLEED_2 FS_HIGH_N 0.00429f
C1956 PULLDOWN_P_R HS_P_13 0.02404f
C1957 HS_N_10 FS_P_BLEED_2 0
C1958 PULLUP_P_BLEED_4 PULLUP_P_WELL 0
C1959 HS_N_12 FS_LOW_P 0.08505f
C1960 PAD_N PULLUP_P_OUT 0.20908f
C1961 HS_P_3 HS_P_0 0.03772f
C1962 FS_N_BLEED_6 VDD 0.00257f
C1963 HS_N_3 FS_N_OUT 0.06167f
C1964 HS_P_13 PULLDOWN_N_R 0.02404f
C1965 HS_N_2 HS_P_5 0.03489f
C1966 HS_N_7 PULLUP_P_OUT 0.03489f
C1967 TERM_GATE_N_BLEED_0 TERM_OR_N_S 0
C1968 HS_P_3 HS_N_5 0.03089f
C1969 PAD_N HS_P_12 0.22324f
C1970 HS_P_10 HS_N_6 0.03097f
C1971 HS_N_0 FS_N_OUT 0.06167f
C1972 HS_PBIAS HS_P_1 2.59892f
C1973 PAD_P DIV_P 2.52939f
C1974 FS_N_BLEED_0 PULLUP_N_WELL 0
C1975 HS_N_4 PULLUP_P_WELL 0.12026f
C1976 HS_N_7 HS_P_12 0.03489f
C1977 DIV_ENABLE FS_LOW_N 0.03554f
C1978 HS_N_8 TERM_GATE_N 0.05073f
C1979 HS_PBIAS PULLUP_N_BLEED_1 0.17672f
C1980 FS_P_GATE HS_N_3 1.03504f
C1981 PULLUP_N_OUT HS_N_6 0.05599f
C1982 a_41005_132945# a_41005_133505# 0.0346f
C1983 HS_N_4 HS_P_2 0.00376f
C1984 PULLUP_P_BLEED_4 HS_N_3 0.0525f
C1985 PULLUP_N_OUT DIV_N 0.04377f
C1986 PULLUP_P_BLEED_0 PULLUP_P_BLEED_1 0.83843f
C1987 HS_N_0 FS_P_GATE 1.02982f
C1988 PULLDOWN_P_R HS_P_4 0.07466f
C1989 PULLUP_P PULLUP_P_OUT 0.00257f
C1990 FS_P_BLEED_5 HS_N_8 0.06178f
C1991 HS_N_1 TERM_OR_N_S 0.02599f
C1992 PAD_P HS_P_7 1.52213f
C1993 HS_P_1 HS_P_5 0.02411f
C1994 HS_N_0 PULLUP_P_BLEED_4 0.05293f
C1995 DIV_ENABLE HS_N_5 0.03089f
C1996 HS_P_4 PULLDOWN_N_R 0.07217f
C1997 HS_N_1 FS_P_CONTROL_S 0.0324f
C1998 FS_LOW_N PULLUP_N_BLEED_6 0.06798f
C1999 TERM_VCM VCM_LOW_OK 0.10492p
C2000 HS_P_10 VDD 6.63169f
C2001 FS_N_BLEED_0 FS_HIGH_N 0.32903f
C2002 HS_N_4 HS_N_3 0.12319p
C2003 TERM_N_R PULLUP_N_CONTROL_S 0.05859f
C2004 FS_N_BLEED_3 FS_N_BLEED_5 0
C2005 PULLUP_N_GATE PULLUP_N_BLEED_1 0.05777f
C2006 PULLUP_N_OUT VDD 5.43573f
C2007 HS_PBIAS HS_P_5 3.80328f
C2008 HS_N_0 HS_N_4 0.04165f
C2009 DIV_P HS_P_12 0.03388f
C2010 TERM_GATE_N_BLEED_2 PULLDOWN_N_R 0.07928f
C2011 HS_P_6 HS_P 3.46603f
C2012 a_41005_132945# ESD_RAIL 0.53823f
C2013 TERM_GATE_N HS_N_7 0.05007f
C2014 TERM_ENABLE HS_N_8 0.04808f
C2015 DIFF_ENABLE TERM_P_R 4.25629f
C2016 TERM_VCM PULLUP_N_BLEED_4 0.02041f
C2017 FS_LOW_P VCM_LOW_OK 0.34798f
C2018 HS_PBIAS PULLUP_N_GATE 0.14584f
C2019 PAD_P HS_P_3 1.68578f
C2020 FS_P_GATE HS_N_10 1.04113f
C2021 HS_N_8 HS_N_9 0.11968p
C2022 HS_N_6 TERM_VCM 0.17751f
C2023 HS_P_7 HS_P_12 0.11376f
C2024 HS_N TERM_GATE_P 0.17562f
C2025 HS_P_6 HS_P_13 0.15959f
C2026 FS_N_GATE FS_HIGH_P 0.13639f
C2027 PULLUP_P_CONTROL_S PULLUP_N_OUT 0.08753f
C2028 FS_P_BLEED_5 HS_N_7 0.06178f
C2029 DIV_ENABLE FS_P_WELL 0.08405f
C2030 TERM_OR_P_NS HS_P_2 0.02846f
C2031 PULLDOWN_P FS_N_GATE 1.24942f
C2032 PULLUP_P_BLEED_4 HS_N_10 0.0527f
C2033 TERM_ENABLE TERM_GATE_P_BLEED_1 0.10319f
C2034 TERM_VCM DIV_N 0.67599f
C2035 HS_P_11 HS_N_12 0.11035f
C2036 FS_LOW_N HS_N_12 0.08441f
C2037 PULLUP_P TERM_GATE_N 0.21883f
C2038 HS_N_8 PULLUP_P_BLEED_6 0.00108f
C2039 HS_N_11 FS_HIGH_P 0.02435f
C2040 PULLUP_P_BLEED_5 PULLDOWN_P 0
C2041 PULLDOWN_P HS_N_11 0.05266f
C2042 HS_N_4 HS_N_10 0
C2043 HS_P_3 PULLUP_P_OUT 0.05276f
C2044 HS_N_6 FS_LOW_P 0.08542f
C2045 PAD_P DIV_ENABLE 0.14682f
C2046 HS_P_0 HS_N_12 0.04378f
C2047 FS_N_BLEED_1 FS_N_BLEED_4 0.0078f
C2048 TERM_OR_P_NS HS_N_3 0.00153f
C2049 FS_N_OUT FS_P_CONTROL_S 0.00663f
C2050 FS_P_BLEED_4 HS_N_12 0.06178f
C2051 TERM_VCM VDD 40.0347f
C2052 HS_N_5 HS_N_12 0
C2053 TERM_OR_P_B HS_P_10 0.09644f
C2054 HS_P_3 HS_P_12 0.02899f
C2055 DIV_N FS_LOW_P 6.0078f
C2056 HS_P_4 HS_P_6 0.06956f
C2057 PAD_N HS_N_9 1.0992f
C2058 TERM_ENABLE HS_N_7 0.10575f
C2059 FS_P_BLEED_6 TERM_P_R 0.04565f
C2060 HS_N_9 HS_N_7 0.04397f
C2061 TERM_OR_P_B PULLUP_N_OUT 0.20772f
C2062 FS_N_BLEED_1 FS_N_WELL 0.5326f
C2063 FS_P_GATE FS_P_CONTROL_S 1.45056f
C2064 FS_N_BLEED_3 PULLUP_N_WELL 0
C2065 VDD FS_LOW_P 3.59076f
C2066 FS_N_BLEED_2 FS_N_BLEED_0 0.12309f
C2067 FS_N_BLEED_1 PULLDOWN_N_R 0.09111f
C2068 TERM_ENABLE PULLUP_P 0.04377f
C2069 PULLUP_P_BLEED_6 HS_N_7 0
C2070 HS_N_1 FS_P_BLEED_0 0.06178f
C2071 PULLUP_P_BLEED_3 TERM_N_R 0.06105f
C2072 HS_N_4 TERM_OR_N_S 0.026f
C2073 HS_N_12 FS_P_WELL 2.00803f
C2074 PULLUP_P HS_N_9 0.02404f
C2075 HS_N_4 FS_P_CONTROL_S 0.03226f
C2076 a_42245_90628# a_44789_117064# 10.1844f
C2077 FS_P_BLEED_0 FS_P_BLEED_2 0
C2078 HS_P_11 VCM_LOW_OK 0.06673f
C2079 PULLUP_P_CONTROL_S FS_LOW_P 0.05888f
C2080 TERM_GATE_P_BLEED_0 HS_P_11 0.03689f
C2081 FS_LOW_N VCM_LOW_OK 0.22524f
C2082 FS_N_BLEED_3 FS_HIGH_N 0
C2083 PULLUP_P PULLUP_P_BLEED_6 0.14694f
C2084 PULLUP_P_BLEED_3 HS_P 0.03489f
C2085 TERM_ENABLE HS_P_7 0.02404f
C2086 HS_N FS_N_GATE 2.07022f
C2087 HS_P_0 VCM_LOW_OK 0.04122f
C2088 FS_P_BLEED_3 PULLUP_P_WELL 0
C2089 TERM_GATE_P_BLEED_0 HS_P_0 0.00591f
C2090 PAD_P HS_N_12 2.18792f
C2091 TERM_OR_P_B TERM_VCM 0.06482f
C2092 HS_N_9 HS_P_7 0.0401f
C2093 HS_N_5 VCM_LOW_OK 0.05893f
C2094 HS_N PULLUP_P_BLEED_5 0.05048f
C2095 TERM_GATE_P_BLEED_0 HS_N_5 0
C2096 HS_N HS_N_11 5.51295f
C2097 DIV_ENABLE TERM_GATE_N 0.02173f
C2098 TERM_GATE_N_BLEED_0 TERM_N_R 0.17977f
C2099 HS_P_11 HS_N_6 0.03089f
C2100 PULLUP_N_OUT HS_N_13 0.05062f
C2101 FS_LOW_N HS_N_6 0.08478f
C2102 FS_LOW_N DIV_N 0.03551f
C2103 TERM_VCM TERM_OR_P_S 0.05962f
C2104 HS_N_12 PULLUP_P_OUT 0.03489f
C2105 TERM_OR_P_NS HS_P_9 0.03937f
C2106 TERM_ENABLE HS_P_3 0.0768f
C2107 TERM_OR_P_B FS_LOW_P 1.1369f
C2108 FS_P_BLEED_3 HS_N_3 0.03144f
C2109 HS_P_0 HS_N_6 0.03737f
C2110 PULLUP_P_GATE TERM_N_R 0.16992f
C2111 HS_N_12 HS_P_12 0.08272f
C2112 HS_N HS_P_8 0.19016f
C2113 TERM_GATE_N_BLEED_0 HS_P 0.03489f
C2114 PULLUP_N PULLUP_N_WELL 0.61243f
C2115 FS_P_BLEED_0 FS_N_OUT 0.28479f
C2116 HS_N_6 HS_N_5 0.12181p
C2117 DIV_LOW_N HS_N_3 0.06178f
C2118 HS_N_1 TERM_N_R 0.06392f
C2119 FS_P_BLEED_4 HS_N_6 0.06231f
C2120 FS_N_CONTROL_S VDD 3.02358f
C2121 HS_N_0 FS_P_BLEED_3 0.02973f
C2122 HS_P_3 HS_N_9 0.03089f
C2123 FS_P_WELL VCM_LOW_OK 1.23126f
C2124 FS_P_BLEED_1 HS_N_8 0.03472f
C2125 HS_P_11 VDD 5.06957f
C2126 FS_LOW_N VDD 2.24181f
C2127 TERM_OR_P_S FS_LOW_P 0.36544f
C2128 HS_N_5 DIV_N 0.03462f
C2129 HS_N_0 DIV_LOW_N 0.06837f
C2130 FS_P_GATE FS_P_BLEED_0 0.16521f
C2131 PULLUP_P_GATE HS_P 0.08871f
C2132 TERM_OR_N_NS HS_N_1 0.03425f
C2133 HS_N_1 HS_P 0.13598f
C2134 PULLDOWN_P_R HS_N_8 0.02404f
C2135 TERM_ENABLE DIV_ENABLE 0.05768f
C2136 HS_P_0 VDD 3.95338f
C2137 FS_P_OUT HS_N_2 0.43576f
C2138 HS_N_2 TERM_P_R 0.0594f
C2139 FS_N_BLEED_2 FS_N_BLEED_3 7.86857f
C2140 PAD_P VCM_LOW_OK 0.00567f
C2141 HS_N_8 PULLDOWN_N_R 0.02404f
C2142 DIV_ENABLE HS_N_9 0.03089f
C2143 HS_N_13 TERM_VCM 0.17f
C2144 HS_N_1 HS_P_13 0.12155f
C2145 HS_N_5 VDD 6.46267f
C2146 PULLUP_P PULLUP_N_BLEED_5 0.10721f
C2147 HS_N_6 FS_P_WELL 1.97843f
C2148 a_44789_117064# a_41005_131545# 0.02879f
C2149 FS_P_BLEED_3 HS_N_10 0.02915f
C2150 PULLDOWN_P_R TERM_GATE_P_BLEED_1 0.01413f
C2151 HS_N_4 FS_P_BLEED_0 0.06178f
C2152 FS_P_WELL DIV_N 0.86039f
C2153 TERM_GATE_N HS_N_12 0.04844f
C2154 FS_P_BLEED_1 HS_N_7 0.03472f
C2155 TERM_ENABLE PULLUP_N_BLEED_6 0.06151f
C2156 PULLDOWN_N_R TERM_GATE_P_BLEED_1 0.00195f
C2157 DIV_LOW_N HS_N_10 0.06178f
C2158 HS_P_1 TERM_P_R 0.10249f
C2159 PAD_N PULLDOWN_P_R 0.0844f
C2160 FS_P_BLEED_5 HS_N_12 0.06178f
C2161 PULLUP_P_CONTROL_S HS_N_5 0.04808f
C2162 PULLUP_P_OUT VCM_LOW_OK 0.13743f
C2163 PULLUP_N PULLDOWN_N 0
C2164 TERM_GATE_P_BLEED_0 PULLUP_P_OUT 0.1011f
C2165 HS_N_13 FS_LOW_P 0.08505f
C2166 PAD_P HS_N_6 2.14046f
C2167 FS_N_OUT TERM_N_R 0.38856f
C2168 HS_P_12 VCM_LOW_OK 0.03489f
C2169 PAD_N PULLDOWN_N_R 4.48191f
C2170 PULLDOWN_P_R HS_N_7 0.02404f
C2171 FS_P_WELL VDD 99.794f
C2172 TERM_GATE_N_BLEED_2 TERM_GATE_N_BLEED_0 0.00153f
C2173 PAD_P DIV_N 0.45367f
C2174 TERM_GATE_P_BLEED_0 HS_P_12 0.03636f
C2175 TERM_P_R TERM_GATE_P_BLEED_2 0.06551f
C2176 PULLUP_P FS_N_BLEED_4 0.05445f
C2177 HS_N_7 PULLDOWN_N_R 0.06832f
C2178 HS_PBIAS FS_P_OUT 0.96844f
C2179 TERM_OR_P_B HS_P_11 0.11938f
C2180 HS_PBIAS TERM_P_R 0.44602f
C2181 DIV_LOW_P DIV_P 0.50398f
C2182 FS_P_GATE TERM_N_R 0.81322f
C2183 PULLUP_N_OUT FS_HIGH_P 0.05082f
C2184 FS_N_BLEED_3 FS_N_BLEED_0 0.10559f
C2185 PULLDOWN_P PULLUP_N_OUT 0.10073f
C2186 TERM_OR_N_NS FS_N_OUT 0.06103f
C2187 FS_N_OUT HS_P 0.77167f
C2188 PULLDOWN_P_R PULLUP_P 0.09196f
C2189 TERM_GATE_N_BLEED_2 HS_N_1 0.02451f
C2190 TERM_OR_P_B HS_P_0 0.09384f
C2191 HS_N_6 PULLUP_P_OUT 0.03489f
C2192 TERM_ENABLE HS_N_12 0.08984f
C2193 PULLUP_N_BLEED_2 PULLUP_N_BLEED_1 1.89414f
C2194 FS_P_OUT HS_P_5 0.05462f
C2195 PULLUP_P FS_N_WELL 1.91861f
C2196 HS_N_11 FS_P_BLEED_6 0.06178f
C2197 PAD_P VDD 0
C2198 HS_P_5 TERM_P_R 0.08374f
C2199 PULLUP_N_BLEED_1 PULLUP_N_BLEED_3 0.06528f
C2200 DIV_N PULLUP_P_OUT 0
C2201 HS_N_9 HS_N_12 0.02504f
C2202 HS_N_6 HS_P_12 0.06578f
C2203 PULLUP_P PULLDOWN_N_R 0.04377f
C2204 TERM_OR_P_B HS_N_5 0.07211f
C2205 FS_P_GATE HS_P 1.05827f
C2206 HS_N_8 HS_P_6 0.04808f
C2207 HS_PBIAS PULLUP_N_BLEED_2 0.01633f
C2208 HS_N_4 TERM_N_R 0.05893f
C2209 PULLUP_P_BLEED_4 HS_P 0.0525f
C2210 PULLUP_N_GATE TERM_P_R 0.15782f
C2211 HS_P_12 DIV_N 0.01246f
C2212 PULLUP_P_BLEED_4 TERM_OR_N_NS 0
C2213 FS_P_GATE HS_P_13 0.19446f
C2214 HS_N_2 TERM_GATE_P 0.10747f
C2215 DIV_P PULLDOWN_N_R 0.01299f
C2216 TERM_GATE_N VCM_LOW_OK 0.01725f
C2217 HS_N FS_N_BLEED_6 0.07097f
C2218 PULLUP_P_OUT VDD 3.24314f
C2219 PULLDOWN_P_R HS_P_7 0.02411f
C2220 PAD_N BYPASS_ENABLE 11.6747f
C2221 a_41005_131825# a_41005_131545# 0.03725f
C2222 HS_PBIAS TERM_OR_N_B 0.01781f
C2223 HS_P_7 PULLDOWN_N_R 0.02418f
C2224 HS_N_4 TERM_OR_N_NS 0.03425f
C2225 HS_N_4 HS_P 0.33321f
C2226 TERM_VCM FS_HIGH_P 0.13992f
C2227 HS_P_12 VDD 4.78775f
C2228 PAD_N HS_P_6 0.31264f
C2229 PULLDOWN_P TERM_VCM 0.18094f
C2230 PULLUP_N_GATE PULLUP_N_BLEED_2 0.06702f
C2231 PULLUP_P_WELL HS_N_3 0.11601f
C2232 PULLUP_P_BLEED_1 PULLUP_P_WELL 0.15492f
C2233 HS_P_1 TERM_GATE_P 0.25434f
C2234 PULLUP_N_GATE PULLUP_N_BLEED_3 0.13233f
C2235 HS_N_0 PULLUP_P_WELL 0.24542f
C2236 HS_N_4 HS_P_13 0.02957f
C2237 HS_N_7 HS_P_6 0.02536f
C2238 PULLUP_N_BLEED_0 PULLUP_N_WELL 5.00789f
C2239 FS_LOW_N HS_N_13 0.08441f
C2240 TERM_GATE_N HS_N_6 0.04962f
C2241 PULLDOWN_P_R HS_P_3 0.07466f
C2242 TERM_GATE_P_BLEED_2 TERM_GATE_P 0.40344f
C2243 TERM_GATE_N DIV_N 0.02552f
C2244 TERM_ENABLE TERM_GATE_P_BLEED_0 0.09803f
C2245 HS_PBIAS TERM_GATE_P 0.02241f
C2246 FS_LOW_P FS_HIGH_P 8.96385f
C2247 HS_N HS_P_10 0.34498f
C2248 FS_P_BLEED_5 HS_N_6 0.06178f
C2249 TERM_ENABLE VCM_LOW_OK 0.27311f
C2250 DIV_ENABLE DIV_LOW_P 2.67093f
C2251 PULLUP_N_BLEED_5 PULLUP_N_BLEED_6 4.58267f
C2252 TERM_OR_P_NS TERM_N_R 0.1011f
C2253 DIV_P BYPASS_ENABLE 0.05958f
C2254 HS_P_3 PULLDOWN_N_R 0.07217f
C2255 HS_N_9 VCM_LOW_OK 0.05893f
C2256 FS_P_BLEED_4 HS_N_13 0.06178f
C2257 HS_N_5 HS_N_13 0.10387f
C2258 DIV_ENABLE FS_P_BLEED_1 0.01375f
C2259 HS_N PULLUP_N_OUT 0.10855f
C2260 DIV_ENABLE FS_N_BLEED_4 0.03564f
C2261 TERM_GATE_P_BLEED_0 HS_N_9 0.00105f
C2262 FS_HIGH_N PULLUP_N_BLEED_0 0.00933f
C2263 HS_N_0 HS_N_3 0.08089f
C2264 TERM_GATE_N VDD 3.74877f
C2265 PULLUP_N_WELL TERM_N_R 0.3392f
C2266 m2_42279_124800# a_41005_133505# 0
C2267 HS_P_5 TERM_GATE_P 0.15599f
C2268 HS_N_4 HS_P_4 0
C2269 PULLUP_P PULLUP_N_CONTROL_S 0.09193f
C2270 DIV_P HS_P_6 0.03388f
C2271 TERM_OR_P_NS HS_P 0.04056f
C2272 PULLUP_P_BLEED_6 VCM_LOW_OK 0
C2273 PULLUP_P_WELL HS_N_10 0.14098f
C2274 TERM_OR_P_B PULLUP_P_OUT 0.19951f
C2275 TERM_ENABLE PULLUP_N_BLEED_4 0.08954f
C2276 DIV_ENABLE FS_N_WELL 0.23482f
C2277 TERM_ENABLE HS_N_6 0.10332f
C2278 DIV_ENABLE PULLDOWN_N_R 0.04455f
C2279 TERM_OR_P_NS HS_P_13 0.02895f
C2280 TERM_GATE_N_BLEED_1 HS_N_11 0.05266f
C2281 PULLUP_N_WELL HS_P 0.25435f
C2282 PULLUP_P_BLEED_3 HS_N_8 0.03489f
C2283 TERM_ENABLE DIV_N 0.00368f
C2284 TERM_OR_P_B HS_P_12 0.13059f
C2285 HS_N_9 HS_N_6 0.04101f
C2286 HS_N_4 TERM_GATE_N_BLEED_2 0.02921f
C2287 HS_P_7 HS_P_6 31.6746f
C2288 FS_HIGH_N TERM_N_R 0.05037f
C2289 HS_N_13 FS_P_WELL 1.99138f
C2290 a_41005_132945# a_41005_131545# 0
C2291 HS_N_9 DIV_N 0.03462f
C2292 PULLUP_P_OUT TERM_OR_P_S 0.00441f
C2293 m2_42279_124800# ESD_RAIL 5.47988f
C2294 PULLUP_P_BLEED_6 HS_N_6 0
C2295 HS_N_3 HS_N_10 0.03951f
C2296 HS_N_2 HS_N_11 0.0256f
C2297 PULLUP_P_BLEED_5 HS_N_2 0.02404f
C2298 RX_P HS_P_0 0
C2299 FS_HIGH_N HS_P 0.03743f
C2300 HS_N TERM_VCM 0.21341f
C2301 TERM_ENABLE VDD 12.7935f
C2302 PULLDOWN_N_R PULLUP_N_BLEED_6 0.04864f
C2303 DIV_LOW_P HS_N_12 0.00136f
C2304 HS_N_0 HS_N_10 2.19255f
C2305 PAD_P HS_N_13 0.08152f
C2306 HS_N_9 VDD 5.99389f
C2307 TERM_OR_P_NS HS_P_4 0.02846f
C2308 PULLUP_P_BLEED_2 TERM_P_R 0.11063f
C2309 a_41764_148611# ESD_RAIL 1.23825p
C2310 PULLDOWN_N TERM_N_R 0.05478f
C2311 FS_P_BLEED_1 HS_N_12 0.03472f
C2312 HS_P_3 HS_P_6 0.07261f
C2313 FS_N_CONTROL_S PULLDOWN_P 0.09439f
C2314 HS_P_9 HS_P_2 0.0419f
C2315 TERM_ENABLE PULLUP_P_CONTROL_S 0
C2316 ESD_RAIL a_43813_117064# 4.89902f
C2317 PULLUP_P_BLEED_3 HS_N_7 0.03489f
C2318 FS_LOW_N FS_HIGH_P 93.2199f
C2319 HS_N FS_LOW_P 0.10015f
C2320 DIV_ENABLE BYPASS_ENABLE 75.0001f
C2321 HS_N_8 TERM_GATE_N_BLEED_0 0.03489f
C2322 PULLDOWN_P FS_LOW_N 0.32402f
C2323 HS_PBIAS FS_N_GATE 3.08633f
C2324 FS_N_WELL HS_N_12 0.00912f
C2325 PULLDOWN_N HS_P 0.03743f
C2326 PULLDOWN_P_R HS_N_12 0.02424f
C2327 HS_N_13 PULLUP_P_OUT 0.03489f
C2328 PULLUP_P_CONTROL_S HS_N_9 0.04808f
C2329 a_53878_132105# a_53878_131545# 0.0346f
C2330 HS_N_3 TERM_OR_N_S 0.02557f
C2331 PULLUP_P_GATE HS_N_8 0.08595f
C2332 PULLUP_P_BLEED_5 HS_PBIAS 0.17636f
C2333 HS_N_12 PULLDOWN_N_R 0.06832f
C2334 HS_PBIAS HS_N_11 2.65494f
C2335 HS_N_13 HS_P_12 0.03621f
C2336 HS_N_3 FS_P_CONTROL_S 0.03226f
C2337 DIV_LOW_N TERM_N_R 0.14472f
C2338 HS_N_0 TERM_OR_N_S 0.02686f
C2339 HS_N_5 FS_HIGH_P 0.02404f
C2340 PULLUP_P_BLEED_3 PULLUP_P 0.27184f
C2341 HS_P_8 HS_P_1 0.02404f
C2342 PULLDOWN_P HS_N_5 0.04428f
C2343 BYPASS_ENABLE PULLUP_N_BLEED_6 0.00766f
C2344 HS_N_0 FS_P_CONTROL_S 0.03296f
C2345 FS_P_BLEED_3 HS_P 0.0834f
C2346 HS_P_5 HS_N_11 0.03489f
C2347 FS_N_BLEED_2 TERM_N_R 0.05729f
C2348 TERM_ENABLE TERM_OR_P_B 5.36669f
C2349 RX_N PAD_N 9.47377f
C2350 PAD_P RX_P 8.57241f
C2351 DIV_LOW_N HS_P 0.06178f
C2352 PULLUP_N_OUT FS_P_BLEED_6 0.11535f
C2353 TERM_GATE_N_BLEED_0 HS_N_7 0.03489f
C2354 HS_P_8 HS_PBIAS 1.54227f
C2355 TERM_VCM DIFF_ENABLE 0.14773f
C2356 PULLUP_N_BLEED_5 PULLUP_N_BLEED_4 3.06975f
C2357 TERM_OR_P_B HS_N_9 0.07254f
C2358 FS_P_WELL FS_HIGH_P 6.72442f
C2359 FS_P_BLEED_1 VCM_LOW_OK 0.0381f
C2360 PAD_N HS_N_1 1.13339f
C2361 HS_N_10 TERM_OR_N_S 0.02545f
C2362 FS_N_BLEED_2 HS_P 0.08856f
C2363 PULLUP_P_GATE HS_N_7 0.08496f
C2364 TERM_ENABLE TERM_OR_P_S 0.23041f
C2365 HS_P_8 HS_P_5 0.00106f
C2366 TERM_GATE_N HS_N_13 0.04808f
C2367 HS_N_7 HS_N_1 0.03096f
C2368 PULLUP_P TERM_GATE_N_BLEED_0 0.05462f
C2369 HS_N_10 FS_P_CONTROL_S 0.03236f
C2370 DIFF_ENABLE FS_LOW_P 0.27413f
C2371 FS_P_OUT TERM_P_R 0.43231f
C2372 TERM_GATE_P_BLEED_0 PULLDOWN_P_R 0.12409f
C2373 PULLDOWN_P_R VCM_LOW_OK 0.06553f
C2374 HS_N FS_N_CONTROL_S 0.12118f
C2375 FS_P_BLEED_5 HS_N_13 0.06178f
C2376 PULLUP_P_WELL FS_P_BLEED_0 0
C2377 TERM_GATE_P_BLEED_0 PULLDOWN_N_R 0.0553f
C2378 FS_N_BLEED_1 PULLUP_N_WELL 0
C2379 HS_N_8 FS_N_OUT 0.06167f
C2380 RX_N DIV_P 0.37599f
C2381 HS_N HS_P_11 0.6688f
C2382 PULLUP_P_GATE PULLUP_P 5.95692f
C2383 PULLUP_N_BLEED_5 VDD 0.55431f
C2384 PULLDOWN_N_R VCM_LOW_OK 0.09227f
C2385 HS_N_12 HS_P_6 0.05906f
C2386 HS_N FS_LOW_N 0.11362f
C2387 FS_P_BLEED_1 HS_N_6 0.03472f
C2388 DIV_LOW_P DIV_N 0.89345f
C2389 PULLUP_P HS_N_1 0.02404f
C2390 TERM_VCM FS_P_BLEED_6 0.01859f
C2391 HS_N HS_P_0 0.54906f
C2392 FS_P_BLEED_1 DIV_N 0.10151f
C2393 FS_P_GATE HS_N_8 1.04761f
C2394 HS_N FS_P_BLEED_4 0.08043f
C2395 PULLUP_P_OUT FS_HIGH_P 0.10214f
C2396 TERM_ENABLE HS_N_13 0.10332f
C2397 FS_N_BLEED_0 HS_P 0.09016f
C2398 HS_N HS_N_5 4.65354f
C2399 PULLDOWN_P_R HS_N_6 0.02404f
C2400 PULLUP_P_BLEED_4 HS_N_8 0.0525f
C2401 FS_N_BLEED_1 FS_HIGH_N 0.01132f
C2402 PULLDOWN_N_R PULLUP_N_BLEED_4 0
C2403 DIV_ENABLE PULLUP_P_BLEED_3 0.01375f
C2404 FS_P_BLEED_1 VDD 0.44675f
C2405 HS_N_3 FS_P_BLEED_0 0.06178f
C2406 FS_N_BLEED_4 VDD 0.45117f
C2407 HS_N_9 HS_N_13 0.08666f
C2408 HS_N_6 PULLDOWN_N_R 0.06832f
C2409 PAD_N FS_N_OUT 4.09186f
C2410 DIV_N PULLDOWN_N_R 0.0471f
C2411 HS_N_4 HS_N_8 0.04079f
C2412 TERM_P_R TERM_OR_N_B 0.37734f
C2413 HS_N_0 FS_P_BLEED_0 0.06178f
C2414 PULLUP_N_BLEED_2 PULLUP_N_BLEED_3 0.39425f
C2415 PULLDOWN_P_R VDD 1.92312f
C2416 FS_N_WELL VDD 0.10242p
C2417 HS_N FS_P_WELL 41.6575f
C2418 PULLUP_N_OUT TERM_GATE_N_BLEED_1 0.09196f
C2419 FS_P_GATE HS_N_7 1.04462f
C2420 PULLDOWN_N_R VDD 2.95843f
C2421 PULLUP_P_WELL TERM_N_R 0.33634f
C2422 TERM_GATE_P_BLEED_0 HS_P_6 0.02404f
C2423 HS_P_3 HS_N_1 0.02599f
C2424 PULLUP_P FS_N_OUT 0.52603f
C2425 HS_P_6 VCM_LOW_OK 0.03489f
C2426 PULLUP_P_BLEED_4 HS_N_7 0.0525f
C2427 TERM_P_R TERM_GATE_P 26.175f
C2428 FS_P_OUT TERM_GATE_P 0.22814f
C2429 HS_P_10 HS_N_2 0.03089f
C2430 HS_PBIAS FS_N_BLEED_6 0.09349f
C2431 FS_LOW_N DIFF_ENABLE 0.20718f
C2432 PULLUP_P_CONTROL_S PULLDOWN_P_R 0.08753f
C2433 DIV_ENABLE TERM_GATE_N_BLEED_0 0.01375f
C2434 TERM_GATE_N FS_HIGH_P 0.00415f
C2435 PAD_N HS_N_4 1.29614f
C2436 DIV_P FS_N_OUT 2.20134f
C2437 RX_N DIV_ENABLE 0.7437f
C2438 PAD_P HS_N 1.23865f
C2439 FS_P_BLEED_0 HS_N_10 0.06178f
C2440 PULLDOWN_P TERM_GATE_N 0.15548f
C2441 PULLUP_P_CONTROL_S PULLDOWN_N_R 0.08753f
C2442 PULLUP_P_WELL HS_P 0.18882f
C2443 DIV_N BYPASS_ENABLE 0.09436f
C2444 PULLUP_P_BLEED_0 PULLUP_P 0.82084f
C2445 HS_N_4 HS_N_7 0.07687f
C2446 a_53878_131545# ESD_RAIL 0.56772f
C2447 PULLUP_P_GATE DIV_ENABLE 0
C2448 PULLUP_P_BLEED_4 PULLUP_P 0.16921f
C2449 TERM_OR_P_NS HS_N_8 0.00704f
C2450 HS_P_2 HS_P 7.07711f
C2451 DIV_ENABLE HS_N_1 0.03212f
C2452 HS_P_10 HS_P_1 37.0279f
C2453 PULLUP_P_BLEED_3 HS_N_12 0.03489f
C2454 PULLUP_P_BLEED_1 TERM_N_R 0.05729f
C2455 HS_N_6 HS_P_6 0.06938f
C2456 HS_N_3 TERM_N_R 0.05893f
C2457 HS_N PULLUP_P_OUT 0.04828f
C2458 DIV_ENABLE FS_P_BLEED_2 0
C2459 HS_P_1 PULLUP_N_OUT 0.05947f
C2460 HS_P_6 DIV_N 0
C2461 HS_N_0 TERM_N_R 0.13438f
C2462 PULLUP_N_GATE FS_N_BLEED_6 0
C2463 VDD BYPASS_ENABLE 0.03959f
C2464 FS_N_BLEED_2 FS_N_BLEED_1 6.33216f
C2465 HS_N_4 PULLUP_P 0.02473f
C2466 HS_P_2 HS_P_13 36.317f
C2467 TERM_GATE_N_BLEED_1 TERM_VCM 0.00966f
C2468 FS_N_BLEED_3 TERM_N_R 0.11444f
C2469 PULLUP_N_OUT PULLUP_N_BLEED_1 0
C2470 TERM_OR_P_B PULLDOWN_P_R 0.17949f
C2471 HS_P_10 HS_PBIAS 8.55407f
C2472 TERM_OR_N_NS HS_N_3 0.03425f
C2473 HS_N_3 HS_P 0.21103f
C2474 TERM_ENABLE FS_HIGH_P 0.01303f
C2475 HS_N HS_P_12 0.5567f
C2476 TERM_OR_P_B PULLDOWN_N_R 0.16954f
C2477 TERM_ENABLE PULLDOWN_P 0.05932f
C2478 HS_N_0 TERM_OR_N_NS 0.03425f
C2479 HS_PBIAS PULLUP_N_OUT 0.76895f
C2480 HS_N_0 HS_P 0.16427f
C2481 FS_N_BLEED_3 HS_P 0.08856f
C2482 HS_N_9 FS_HIGH_P 0.02404f
C2483 HS_P_6 VDD 6.8233f
C2484 FS_P_BLEED_0 FS_P_CONTROL_S 0.00276f
C2485 HS_N_2 TERM_VCM 0.12019f
C2486 HS_N_3 HS_P_13 0.02404f
C2487 PULLUP_P_CONTROL_S BYPASS_ENABLE 0.00444f
C2488 HS_P_10 HS_P_5 0.0481f
C2489 TERM_GATE_N_BLEED_1 FS_LOW_P 0.05872f
C2490 VDD PULLUP_N_CONTROL_S 0.68736f
C2491 TERM_OR_P_NS HS_N_7 0.00491f
C2492 HS_N_0 HS_P_13 0.02661f
C2493 FS_P_BLEED_4 FS_P_BLEED_6 0.12309f
C2494 TERM_GATE_N_BLEED_0 HS_N_12 0.03489f
C2495 HS_N_5 FS_P_BLEED_6 0.06178f
C2496 HS_N_10 TERM_N_R 0.06034f
C2497 HS_P_4 HS_P_2 0.03986f
C2498 PULLUP_N_OUT HS_P_5 0.02859f
C2499 PULLDOWN_P PULLUP_P_BLEED_6 0.09848f
C2500 PULLUP_N PULLUP_N_BLEED_0 0.85278f
C2501 PULLUP_P_GATE HS_N_12 0.08333f
C2502 HS_P_1 TERM_VCM 0.15005f
C2503 FS_N_BLEED_1 FS_N_BLEED_0 4.78029f
C2504 PULLUP_N_OUT PULLUP_N_GATE 16.6062f
C2505 HS_N_2 FS_LOW_P 0.08505f
C2506 DIV_LOW_P HS_N_13 0.00103f
C2507 FS_N_GATE TERM_P_R 0.72109f
C2508 a_42245_90628# a_43813_117064# 0.00994f
C2509 DIV_ENABLE FS_N_OUT 0.15376f
C2510 HS_N_1 HS_N_12 0.03364f
C2511 TERM_OR_N_NS HS_N_10 0.03425f
C2512 HS_N TERM_GATE_N 0.08686f
C2513 HS_N_10 HS_P 0.25322f
C2514 PULLUP_P_BLEED_3 VCM_LOW_OK 0.03823f
C2515 FS_P_BLEED_1 HS_N_13 0.03472f
C2516 HS_N_12 FS_P_BLEED_2 0
C2517 FS_P_OUT HS_N_11 0.43976f
C2518 PULLUP_P PULLUP_N_WELL 9.02284f
C2519 HS_N_4 HS_P_3 0.00972f
C2520 HS_N_11 TERM_P_R 0.05996f
C2521 HS_N FS_P_BLEED_5 0.08043f
C2522 HS_P_13 HS_N_10 0.0252f
C2523 TERM_VCM TERM_GATE_P_BLEED_2 0.02194f
C2524 DIV_ENABLE FS_P_GATE 0.00424f
C2525 HS_PBIAS TERM_VCM 0.70648f
C2526 PULLDOWN_P_R HS_N_13 0.02404f
C2527 HS_P_1 FS_LOW_P 0.11262f
C2528 FS_N_WELL HS_N_13 0.00988f
C2529 PULLUP_N TERM_N_R 0.12734f
C2530 DIV_ENABLE PULLUP_P_BLEED_4 0
C2531 TERM_GATE_N_BLEED_2 HS_N_3 0.02807f
C2532 TERM_N_R TERM_OR_N_S 0.12114f
C2533 FS_P_BLEED_3 HS_N_8 0.04176f
C2534 TERM_OR_P_NS HS_P_7 0.02846f
C2535 HS_N_13 PULLDOWN_N_R 0.06832f
C2536 DIV_ENABLE FS_N_BLEED_5 0
C2537 TERM_OR_P_B HS_P_6 0.10133f
C2538 TERM_VCM HS_P_5 0.09615f
C2539 PULLUP_P_BLEED_3 HS_N_6 0.03489f
C2540 HS_N_0 TERM_GATE_N_BLEED_2 0.02492f
C2541 DIV_LOW_N HS_N_8 0.06178f
C2542 HS_P_8 TERM_P_R 0.08296f
C2543 PULLUP_P FS_HIGH_N 0.04377f
C2544 PULLUP_P_BLEED_3 DIV_N 0.10151f
C2545 HS_PBIAS FS_LOW_P 0.34356f
C2546 DIV_ENABLE HS_N_4 0.03089f
C2547 TERM_ENABLE HS_N 0.07737f
C2548 PULLUP_N_GATE TERM_VCM 0.19338f
C2549 TERM_OR_N_NS TERM_OR_N_S 0.00164f
C2550 HS_P TERM_OR_N_S 0.05632f
C2551 HS_P_9 HS_P 6.36218f
C2552 HS_N HS_N_9 5.97147f
C2553 HS_P FS_P_CONTROL_S 0.03246f
C2554 HS_P_9 HS_P_13 0.04877f
C2555 FS_LOW_N TERM_GATE_N_BLEED_1 0.0839f
C2556 HS_P_5 FS_LOW_P 0.17341f
C2557 m2_42279_124800# a_41005_131545# 0.05457f
C2558 PULLUP_P_GATE VCM_LOW_OK 0.22296f
C2559 PULLUP_P_BLEED_3 VDD 0.44664f
C2560 TERM_OR_P_NS HS_P_3 0.02846f
C2561 FS_P_BLEED_6 PULLUP_P_OUT 0.15208f
C2562 HS_N_1 VCM_LOW_OK 0.05893f
C2563 FS_P_BLEED_3 HS_N_7 0.03794f
C2564 TERM_GATE_N_BLEED_2 HS_N_10 0.02441f
C2565 PULLUP_N_GATE FS_LOW_P 0.10761f
C2566 PULLDOWN_P PULLUP_N_BLEED_5 0
C2567 FS_P_GATE HS_N_12 1.03841f
C2568 TERM_GATE_N_BLEED_0 HS_N_6 0.03489f
C2569 TERM_GATE_N_BLEED_1 HS_N_5 0.0525f
C2570 FS_LOW_N HS_N_2 0.08441f
C2571 HS_P_11 HS_N_2 0.03089f
C2572 DIV_LOW_N HS_N_7 0.06178f
C2573 ATB_ESD_RAIL VSS 0.86326f
C2574 RX_N VSS 44.4745f
C2575 RX_P VSS 43.7342f
C2576 BYPASS_ENABLE VSS 60.3857f
C2577 HS_N VSS 56.645f
C2578 HS_P VSS 40.6501f
C2579 PAD_P VSS 0.37048p
C2580 PAD_N VSS 0.36624p
C2581 FS_LOW_P VSS 38.0085f
C2582 TERM_ENABLE VSS 51.3239f
C2583 DIV_ENABLE VSS 22.9277f
C2584 TERM_VCM VSS 0.11353p
C2585 HS_PBIAS VSS 49.4032f
C2586 FS_HIGH_P VSS 8.62107f
C2587 PULLUP_P VSS 19.459f
C2588 PULLDOWN_P VSS 14.2957f
C2589 FS_LOW_N VSS 8.47881f
C2590 FS_HIGH_N VSS 4.29973f
C2591 PULLUP_N VSS 3.12827f
C2592 DIFF_ENABLE VSS 21.3621f
C2593 PULLDOWN_N VSS 4.99637f
C2594 ESD_RAIL VSS 1858.285664f
C2595 VDD VSS 0.72412p
C2596 m2_42279_124800# VSS 7.46506f $ **FLOATING
C2597 a_42245_90628# VSS 0.24984p
C2598 a_44789_117064# VSS 12.0947f
C2599 a_43813_117064# VSS 5.60447f
C2600 TERM_OR_P_S VSS 3.53275f
C2601 TERM_OR_P_NS VSS 10.064f
C2602 a_41005_131545# VSS 0.10822p
C2603 a_53878_131545# VSS 0.07835f
C2604 a_41005_131825# VSS 0.07377f
C2605 a_53878_132105# VSS 0.07394f
C2606 a_41005_132385# VSS 0.07377f
C2607 a_53878_132665# VSS 0.07394f
C2608 a_41005_132945# VSS 0.07377f
C2609 a_53878_133225# VSS 0.07394f
C2610 a_41005_133505# VSS 0.07377f
C2611 a_53878_133785# VSS 0.07394f
C2612 a_41005_134065# VSS 0.07377f
C2613 TERM_GATE_P_BLEED_2 VSS 3.28565f
C2614 TERM_GATE_P_BLEED_1 VSS 5.10072f
C2615 TERM_GATE_P_BLEED_0 VSS 7.68181f
C2616 TERM_OR_P_B VSS 21.1533f
C2617 a_53878_134345# VSS 0.07838f
C2618 TERM_GATE_P VSS 27.0289f
C2619 HS_P_4 VSS 7.08828f
C2620 HS_P_3 VSS 7.10742f
C2621 HS_P_2 VSS 6.92881f
C2622 HS_P_1 VSS 5.64833f
C2623 HS_P_0 VSS 7.04643f
C2624 DIV_LOW_P VSS 7.23693f
C2625 DIV_P VSS 14.1199f
C2626 HS_P_11 VSS 8.66739f
C2627 HS_P_10 VSS 6.56271f
C2628 HS_P_9 VSS 7.07186f
C2629 HS_P_8 VSS 5.68784f
C2630 HS_P_7 VSS 4.83585f
C2631 HS_P_6 VSS 5.96193f
C2632 HS_P_5 VSS 7.82827f
C2633 HS_P_13 VSS 6.1434f
C2634 HS_P_12 VSS 7.62117f
C2635 a_41764_148611# VSS 0.46881p
C2636 a_41764_160995# VSS 1.7103p
C2637 FS_P_BLEED_0 VSS 5.25478f
C2638 FS_P_CONTROL_S VSS 4.50476f
C2639 FS_P_OUT VSS 33.2921f
C2640 FS_P_GATE VSS 50.584f
C2641 FS_P_BLEED_6 VSS 4.71981f
C2642 FS_P_BLEED_5 VSS 4.09514f
C2643 FS_P_BLEED_4 VSS 3.52334f
C2644 FS_P_BLEED_3 VSS 3.16733f
C2645 FS_P_BLEED_2 VSS 3.71625f
C2646 FS_P_BLEED_1 VSS 8.07846f
C2647 PULLUP_P_OUT VSS 22.0369f
C2648 PULLUP_P_BLEED_2 VSS 4.21729f
C2649 PULLUP_P_BLEED_1 VSS 3.22052f
C2650 PULLUP_P_BLEED_0 VSS 3.1427f
C2651 PULLUP_P_CONTROL_S VSS 14.2222f
C2652 PULLDOWN_P_R VSS 21.8133f
C2653 PULLUP_P_GATE VSS 18.622f
C2654 PULLUP_P_BLEED_6 VSS 5.9721f
C2655 PULLUP_P_BLEED_5 VSS 8.83533f
C2656 PULLUP_P_BLEED_4 VSS 11.7853f
C2657 PULLUP_P_BLEED_3 VSS 8.31118f
C2658 TERM_OR_N_B VSS 9.20695f
C2659 TERM_OR_N_S VSS 8.30319f
C2660 TERM_OR_N_NS VSS 5.94472f
C2661 VCM_LOW_OK VSS 25.8357f
C2662 TERM_GATE_N_BLEED_2 VSS 14.3664f
C2663 TERM_GATE_N_BLEED_1 VSS 13.4026f
C2664 TERM_GATE_N_BLEED_0 VSS 8.30278f
C2665 HS_N_0 VSS 11.8194f
C2666 DIV_LOW_N VSS 8.79168f
C2667 DIV_N VSS 18.8798f
C2668 TERM_GATE_N VSS 18.495f
C2669 HS_N_7 VSS 9.28359f
C2670 HS_N_6 VSS 9.29898f
C2671 HS_N_5 VSS 8.48041f
C2672 HS_N_4 VSS 7.55183f
C2673 HS_N_3 VSS 7.91514f
C2674 HS_N_2 VSS 8.95462f
C2675 HS_N_1 VSS 9.59159f
C2676 HS_N_13 VSS 9.06212f
C2677 HS_N_12 VSS 9.99856f
C2678 HS_N_11 VSS 9.36849f
C2679 HS_N_10 VSS 9.03359f
C2680 HS_N_9 VSS 8.5391f
C2681 HS_N_8 VSS 9.00333f
C2682 FS_N_CONTROL_S VSS 6.67541f
C2683 FS_N_OUT VSS 66.0491f
C2684 FS_N_BLEED_3 VSS 5.83837f
C2685 FS_N_BLEED_2 VSS 4.75153f
C2686 FS_N_BLEED_1 VSS 4.13355f
C2687 FS_N_BLEED_0 VSS 3.57892f
C2688 FS_N_GATE VSS 51.2723f
C2689 FS_N_BLEED_6 VSS 3.35184f
C2690 FS_N_BLEED_5 VSS 3.45768f
C2691 FS_N_BLEED_4 VSS 8.08501f
C2692 PULLUP_N_CONTROL_S VSS 4.4075f
C2693 PULLUP_N_OUT VSS 44.4704f
C2694 PULLUP_N_BLEED_5 VSS 4.51663f
C2695 PULLUP_N_BLEED_4 VSS 3.53996f
C2696 PULLUP_N_BLEED_3 VSS 2.95235f
C2697 PULLUP_N_BLEED_2 VSS 3.88779f
C2698 PULLUP_N_BLEED_1 VSS 6.69252f
C2699 PULLUP_N_BLEED_0 VSS 9.62445f
C2700 TERM_P_R VSS 90.06779f
C2701 TERM_N_R VSS 0.10882p
C2702 PULLDOWN_N_R VSS 36.5261f
C2703 PULLUP_N_GATE VSS 18.208f
C2704 PULLUP_N_BLEED_6 VSS 8.22239f
C2705 FS_P_WELL VSS 0.43173p
C2706 PULLUP_P_WELL VSS 97.9489f
C2707 FS_N_WELL VSS 0.43826p
C2708 PULLUP_N_WELL VSS 0.10052p
DWELL_ARRAY VSS ESD_RAIL diode_nw2ps_06v0 area=569.4528p pj=470.72u
.ends

.lib /home/ubuntu/svalbard/scratch/transceiver-pad-pdk/ngspice/sm141064.ngspice diode_typical
.lib /home/ubuntu/svalbard/scratch/transceiver-pad-pdk/ngspice/sm141064.ngspice mimcap_typical
