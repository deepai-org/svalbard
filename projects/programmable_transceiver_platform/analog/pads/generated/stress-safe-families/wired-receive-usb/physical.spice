.subckt tx_protected_pad PAD_P PAD_N VDD VSS TERM_VCM TERM_ENABLE DIFF_ENABLE DIV_ENABLE BYPASS_ENABLE RX_P RX_N HS_PBIAS HS_P HS_N FS_HIGH_P FS_HIGH_N FS_LOW_P FS_LOW_N PULLUP_P PULLUP_N PULLDOWN_P PULLDOWN_N TERM_TRIM0 TERM_TRIM1 TERM_TRIM2 LS_SLOW DVDD
XPHYSICAL PAD_P PAD_N VDD VSS TERM_VCM TERM_ENABLE DIFF_ENABLE DIV_ENABLE BYPASS_ENABLE RX_P RX_N HS_PBIAS HS_P HS_N FS_HIGH_P FS_HIGH_N FS_LOW_P FS_LOW_N PULLUP_P PULLUP_N PULLDOWN_P PULLDOWN_N TERM_TRIM0 TERM_TRIM1 TERM_TRIM2 LS_SLOW DVDD combined_flat
.ends tx_protected_pad
* NGSPICE file created from combined_flat.ext - technology: gf180mcuD

.subckt combined_flat PAD_P PAD_N VDD VSS TERM_VCM TERM_ENABLE DIFF_ENABLE DIV_ENABLE
+ BYPASS_ENABLE RX_P RX_N HS_PBIAS HS_P HS_N FS_HIGH_P FS_HIGH_N FS_LOW_P FS_LOW_N
+ PULLUP_P PULLUP_N PULLDOWN_P PULLDOWN_N TERM_TRIM0 TERM_TRIM1 TERM_TRIM2 LS_SLOW
+ DVDD
X0 HS_N_1 HS_PBIAS VDD VDD pfet_03v3 ad=8.8p pd=40.88u as=8.8p ps=40.88u w=20u l=1u
X1 HS_N_8 HS_N PAD_N VSS nfet_06v0 ad=8.8p pd=40.88u as=8.8p ps=40.88u w=20u l=0.7u
X2 TERM_GATE_P_BLEED_1 TERM_GATE_P_BLEED_2 VSS ppolyf_u_1k r_width=1u r_length=12.5u
X3 VDD FS_N_GATE FS_N_WELL FS_N_WELL pfet_06v0 ad=3.64p pd=14.52u as=3.64p ps=14.52u w=14u l=0.55u
X4 PAD_P PULLDOWN_P_R VSS ppolyf_u_1k r_width=1u r_length=14.2u
X5 FS_N_WELL FS_N_GATE VDD FS_N_WELL pfet_06v0 ad=3.64p pd=14.52u as=3.64p ps=14.52u w=14u l=0.55u
X6 VDD FS_N_GATE FS_N_WELL FS_N_WELL pfet_06v0 ad=3.64p pd=14.52u as=3.64p ps=14.52u w=14u l=0.55u
X7 PULLUP_N_GATE VDD PULLUP_N_WELL PULLUP_N_WELL pfet_06v0 ad=1.76p pd=8.88u as=1.76p ps=8.88u w=4u l=0.55u
X8 HS_P_10 HS_PBIAS VDD VDD pfet_03v3 ad=8.8p pd=40.88u as=8.8p ps=40.88u w=20u l=1u
X9 FS_N_WELL FS_N_GATE VDD FS_N_WELL pfet_06v0 ad=3.64p pd=14.52u as=3.64p ps=14.52u w=14u l=0.55u
X10 TERM_OR_P_B VCM_LOW_OK TERM_OR_P_S VDD pfet_03v3 ad=2.7808p pd=13.52u as=2.7808p ps=13.52u w=6.32u l=0.28u
X11 FS_P_WELL FS_P_GATE VDD FS_P_WELL pfet_06v0 ad=3.64p pd=14.52u as=3.64p ps=14.52u w=14u l=0.55u
X12 TERM_N_R PAD_N VSS ppolyf_u r_width=16u r_length=1.16u
X13 PULLUP_N_WELL PULLUP_N_GATE PULLUP_N_OUT PULLUP_N_WELL pfet_03v3 ad=8.8p pd=40.88u as=5.2p ps=20.52u w=20u l=0.28u
X14 FS_P_BLEED_3 FS_P_BLEED_4 VSS ppolyf_u_1k r_width=1u r_length=12.5u
X15 HS_N_7 HS_N PAD_N VSS nfet_06v0 ad=8.8p pd=40.88u as=8.8p ps=40.88u w=20u l=0.7u
X16 FS_N_WELL FS_N_GATE FS_N_OUT FS_N_WELL pfet_06v0 ad=3.64p pd=14.52u as=3.64p ps=14.52u w=14u l=0.55u
X17 FS_N_OUT FS_N_GATE FS_N_WELL FS_N_WELL pfet_06v0 ad=3.64p pd=14.52u as=3.64p ps=14.52u w=14u l=0.55u
X18 PULLUP_N_WELL PULLUP_N_GATE PULLUP_N_OUT PULLUP_N_WELL pfet_03v3 ad=8.8p pd=40.88u as=5.2p ps=20.52u w=20u l=0.28u
X19 PULLUP_N_WELL PULLUP_N_BLEED_0 VSS ppolyf_u_1k r_width=1u r_length=12.5u
X20 FS_P_WELL FS_P_GATE VDD FS_P_WELL pfet_06v0 ad=3.64p pd=14.52u as=3.64p ps=14.52u w=14u l=0.55u
X21 FS_N_WELL FS_N_GATE FS_N_OUT FS_N_WELL pfet_06v0 ad=3.64p pd=14.52u as=3.64p ps=14.52u w=14u l=0.55u
X22 FS_N_WELL FS_N_GATE FS_N_OUT FS_N_WELL pfet_06v0 ad=3.64p pd=14.52u as=3.64p ps=14.52u w=14u l=0.55u
X23 FS_N_BLEED_4 FS_N_BLEED_5 VSS ppolyf_u_1k r_width=1u r_length=12.5u
X24 VDD FS_P_GATE FS_P_WELL FS_P_WELL pfet_06v0 ad=3.64p pd=14.52u as=3.64p ps=14.52u w=14u l=0.55u
D0 PAD_N DVDD diode_pd2nw_06v0 pj=51.8u area=22.5p
X25 PAD_N BYPASS_ENABLE RX_N VSS nfet_06v0 ad=5.2p pd=20.52u as=8.8p ps=40.88u w=20u l=0.7u
X26 FS_P_WELL FS_P_GATE FS_P_OUT FS_P_WELL pfet_06v0 ad=3.64p pd=14.52u as=3.64p ps=14.52u w=14u l=0.55u
X27 FS_P_OUT FS_P_GATE FS_P_WELL FS_P_WELL pfet_06v0 ad=3.64p pd=14.52u as=3.64p ps=14.52u w=14u l=0.55u
X28 HS_N_11 HS_PBIAS VDD VDD pfet_03v3 ad=8.8p pd=40.88u as=8.8p ps=40.88u w=20u l=1u
X29 RX_P BYPASS_ENABLE PAD_P VSS nfet_06v0 ad=8.8p pd=40.88u as=5.2p ps=20.52u w=20u l=0.7u
X30 FS_P_WELL FS_P_GATE FS_P_OUT FS_P_WELL pfet_06v0 ad=3.64p pd=14.52u as=3.64p ps=14.52u w=14u l=0.55u
X31 FS_P_OUT FS_P_GATE FS_P_WELL FS_P_WELL pfet_06v0 ad=3.64p pd=14.52u as=3.64p ps=14.52u w=14u l=0.55u
X32 LSM_H_N FS_N_GATE cap_mim_2f0_m4m5_noshield c_width=27.4u c_length=27.4u
X33 FS_P_OUT FS_P_GATE FS_P_WELL FS_P_WELL pfet_06v0 ad=3.64p pd=14.52u as=3.64p ps=14.52u w=14u l=0.55u
X34 TERM_P_R DIFF_ENABLE TERM_N_R VSS nfet_06v0 ad=8.8p pd=40.88u as=8.8p ps=40.88u w=20u l=0.7u
X35 FS_N_BLEED_0 FS_N_BLEED_1 VSS ppolyf_u_1k r_width=1u r_length=12.5u
X36 PULLUP_P_WELL PULLUP_P_GATE PULLUP_P_OUT PULLUP_P_WELL pfet_03v3 ad=8.8p pd=40.88u as=5.2p ps=20.52u w=20u l=0.28u
X37 TERM_P_R LS_SLOW LSM_L_P VSS nfet_06v0 ad=1.76p pd=8.88u as=1.76p ps=8.88u w=4u l=0.7u
X38 FS_N_WELL FS_N_GATE FS_N_OUT FS_N_WELL pfet_06v0 ad=6.16p pd=28.88u as=3.64p ps=14.52u w=14u l=0.55u
X39 PULLUP_N_CONTROL_S VDD VSS VSS nfet_06v0 ad=1.76p pd=8.88u as=1.76p ps=8.88u w=4u l=0.7u
X40 PULLUP_N_WELL PULLUP_N_GATE VDD PULLUP_N_WELL pfet_06v0 ad=8.8p pd=40.88u as=5.2p ps=20.52u w=20u l=0.55u
X41 HS_N_5 HS_PBIAS VDD VDD pfet_03v3 ad=8.8p pd=40.88u as=8.8p ps=40.88u w=20u l=1u
X42 PULLDOWN_P_R PULLDOWN_P VSS VSS nfet_06v0 ad=3.52p pd=16.88u as=3.52p ps=16.88u w=8u l=0.7u
X43 VDD PULLUP_P_GATE PULLUP_P_WELL PULLUP_P_WELL pfet_06v0 ad=5.2p pd=20.52u as=8.8p ps=40.88u w=20u l=0.55u
X44 TERM_GATE_P_BLEED_5 TERM_GATE_P_BLEED_6 VSS ppolyf_u_1k r_width=1u r_length=12.5u
X45 HS_N_10 HS_N PAD_N VSS nfet_06v0 ad=8.8p pd=40.88u as=8.8p ps=40.88u w=20u l=0.7u
X46 VDD FS_P_GATE FS_P_WELL FS_P_WELL pfet_06v0 ad=3.64p pd=14.52u as=3.64p ps=14.52u w=14u l=0.55u
X47 PULLUP_N_WELL PULLUP_N_GATE VDD PULLUP_N_WELL pfet_06v0 ad=8.8p pd=40.88u as=5.2p ps=20.52u w=20u l=0.55u
X48 HS_N_7 HS_PBIAS VDD VDD pfet_03v3 ad=8.8p pd=40.88u as=8.8p ps=40.88u w=20u l=1u
X49 PULLUP_P_BLEED_3 PULLUP_P_BLEED_4 VSS ppolyf_u_1k r_width=1u r_length=12.5u
D1 VSS PAD_N diode_nd2ps_06v0 pj=51.8u area=22.5p
X50 TERM_P_R DIFF_ENABLE TERM_N_R VSS nfet_06v0 ad=8.8p pd=40.88u as=8.8p ps=40.88u w=20u l=0.7u
X51 FS_N_GATE FS_HIGH_N FS_N_WELL FS_N_WELL pfet_06v0 ad=7.04p pd=32.88u as=7.04p ps=32.88u w=16u l=0.55u
D2 VSS PAD_P diode_nd2ps_06v0 pj=51.8u area=22.5p
D3 PAD_N DVDD diode_pd2nw_06v0 pj=51.8u area=22.5p
X52 FS_N_WELL FS_N_GATE VDD FS_N_WELL pfet_06v0 ad=3.64p pd=14.52u as=3.64p ps=14.52u w=14u l=0.55u
X53 TERM_N_R TERM_GATE_N TERM_VCM VSS nfet_06v0 ad=5.2p pd=20.52u as=5.2p ps=20.52u w=20u l=0.7u
X54 HS_P_13 HS_PBIAS VDD VDD pfet_03v3 ad=8.8p pd=40.88u as=8.8p ps=40.88u w=20u l=1u
X55 HS_P_1 HS_P PAD_P VSS nfet_06v0 ad=8.8p pd=40.88u as=8.8p ps=40.88u w=20u l=0.7u
D4 PAD_P DVDD diode_pd2nw_06v0 pj=51.8u area=22.5p
X56 FS_N_WELL FS_N_GATE VDD FS_N_WELL pfet_06v0 ad=3.64p pd=14.52u as=3.64p ps=14.52u w=14u l=0.55u
X57 HS_N_9 HS_N PAD_N VSS nfet_06v0 ad=8.8p pd=40.88u as=8.8p ps=40.88u w=20u l=0.7u
X58 PAD_P BYPASS_ENABLE RX_P VSS nfet_06v0 ad=5.2p pd=20.52u as=8.8p ps=40.88u w=20u l=0.7u
X59 DIV_P DIV_ENABLE RX_P VSS nfet_06v0 ad=8.8p pd=40.88u as=8.8p ps=40.88u w=20u l=0.7u
X60 VDD FS_N_GATE FS_N_WELL FS_N_WELL pfet_06v0 ad=3.64p pd=14.52u as=3.64p ps=14.52u w=14u l=0.55u
X61 FS_N_WELL FS_N_GATE VDD FS_N_WELL pfet_06v0 ad=3.64p pd=14.52u as=3.64p ps=14.52u w=14u l=0.55u
X62 DIV_LOW_N DIV_ENABLE VSS VSS nfet_06v0 ad=8.8p pd=40.88u as=8.8p ps=40.88u w=20u l=0.7u
X63 PULLUP_P_BLEED_1 PULLUP_P_BLEED_2 VSS ppolyf_u_1k r_width=1u r_length=12.5u
X64 TERM_LS_P_S HS_PBIAS VDD VDD pfet_03v3 ad=0.352p pd=2.48u as=0.352p ps=2.48u w=0.8u l=1u
X65 TRIM_P_2_R TERM_TRIM2 TERM_VCM VSS nfet_06v0 ad=8.8p pd=40.88u as=8.8p ps=40.88u w=20u l=0.7u
X66 FS_P_BLEED_6 FS_P_GATE VSS ppolyf_u_1k r_width=1u r_length=12.5u
X67 HS_P_1 HS_PBIAS VDD VDD pfet_03v3 ad=8.8p pd=40.88u as=8.8p ps=40.88u w=20u l=1u
X68 FS_N_WELL FS_N_GATE FS_N_OUT FS_N_WELL pfet_06v0 ad=3.64p pd=14.52u as=3.64p ps=14.52u w=14u l=0.55u
X69 FS_N_WELL FS_N_GATE FS_N_OUT FS_N_WELL pfet_06v0 ad=3.64p pd=14.52u as=3.64p ps=14.52u w=14u l=0.55u
X70 TERM_GATE_N_BLEED_6 VSS VSS ppolyf_u_1k r_width=1u r_length=12.5u
X71 VDD FS_P_GATE FS_P_WELL FS_P_WELL pfet_06v0 ad=3.64p pd=14.52u as=3.64p ps=14.52u w=14u l=0.55u
X72 FS_N_OUT FS_N_GATE FS_N_WELL FS_N_WELL pfet_06v0 ad=3.64p pd=14.52u as=3.64p ps=14.52u w=14u l=0.55u
X73 TERM_VCM TERM_GATE_N TERM_N_R VSS nfet_06v0 ad=5.2p pd=20.52u as=5.2p ps=20.52u w=20u l=0.7u
X74 DIV_N DIV_LOW_N VSS ppolyf_u_1k r_width=1u r_length=2u
X75 HS_N_5 HS_N PAD_N VSS nfet_06v0 ad=8.8p pd=40.88u as=8.8p ps=40.88u w=20u l=0.7u
X76 VDD FS_P_GATE FS_P_WELL FS_P_WELL pfet_06v0 ad=3.64p pd=14.52u as=3.64p ps=14.52u w=14u l=0.55u
X77 FS_P_WELL FS_P_GATE VDD FS_P_WELL pfet_06v0 ad=6.16p pd=28.88u as=3.64p ps=14.52u w=14u l=0.55u
X78 FS_N_OUT FS_N_GATE FS_N_WELL FS_N_WELL pfet_06v0 ad=3.64p pd=14.52u as=3.64p ps=14.52u w=14u l=0.55u
X79 VCM_LOW_OK TERM_VCM VDD VDD pfet_03v3 ad=0.88p pd=4.88u as=0.88p ps=4.88u w=2u l=0.28u
X80 TERM_VCM TERM_GATE_P TERM_P_R VSS nfet_06v0 ad=5.2p pd=20.52u as=5.2p ps=20.52u w=20u l=0.7u
X81 TRIM_P_1_R PAD_P VSS ppolyf_u r_width=8u r_length=1.2u
X82 FS_P_OUT FS_P_GATE FS_P_WELL FS_P_WELL pfet_06v0 ad=3.64p pd=14.52u as=3.64p ps=14.52u w=14u l=0.55u
D5 VSS PAD_N diode_nd2ps_06v0 pj=51.8u area=22.5p
X83 TERM_GATE_N_BLEED_0 TERM_GATE_N_BLEED_1 VSS ppolyf_u_1k r_width=1u r_length=12.5u
X84 TERM_GATE_N_BLEED_2 TERM_GATE_N_BLEED_3 VSS ppolyf_u_1k r_width=1u r_length=12.5u
X85 FS_P_WELL FS_P_GATE FS_P_OUT FS_P_WELL pfet_06v0 ad=6.16p pd=28.88u as=3.64p ps=14.52u w=14u l=0.55u
X86 HS_N_3 HS_N PAD_N VSS nfet_06v0 ad=8.8p pd=40.88u as=8.8p ps=40.88u w=20u l=0.7u
X87 LSNB HS_PBIAS VDD VDD pfet_03v3 ad=0.352p pd=2.48u as=0.352p ps=2.48u w=0.8u l=1u
X88 VCM_LOW_OK TERM_VCM VSS VSS nfet_03v3 ad=3.52p pd=16.88u as=3.52p ps=16.88u w=8u l=0.28u
X89 TERM_OR_P_B FS_LOW_P TERM_OR_P_NS VSS nfet_03v3 ad=1.3904p pd=7.2u as=1.3904p ps=7.2u w=3.16u l=0.28u
X90 TERM_N_R LS_SLOW_B LSM_L_N FS_N_WELL pfet_06v0 ad=1.76p pd=8.88u as=1.76p ps=8.88u w=4u l=0.55u
X91 PULLUP_P_BLEED_5 PULLUP_P_BLEED_6 VSS ppolyf_u_1k r_width=1u r_length=12.5u
X92 FS_P_GATE FS_HIGH_P FS_P_CONTROL_S VSS nfet_06v0 ad=7.04p pd=32.88u as=7.04p ps=32.88u w=16u l=0.7u
X93 TERM_VCM TERM_GATE_N TERM_N_R VSS nfet_06v0 ad=5.2p pd=20.52u as=5.2p ps=20.52u w=20u l=0.7u
X94 PULLUP_N_BLEED_6 PULLUP_N_GATE VSS ppolyf_u_1k r_width=1u r_length=12.5u
X95 TERM_LS_N_S LS_SLOW VDD VDD pfet_03v3 ad=3.52p pd=16.88u as=3.52p ps=16.88u w=8u l=0.28u
X96 HS_P_9 HS_PBIAS VDD VDD pfet_03v3 ad=8.8p pd=40.88u as=8.8p ps=40.88u w=20u l=1u
X97 TERM_P_R PAD_P VSS ppolyf_u r_width=16u r_length=1.16u
X98 TERM_P_R TERM_GATE_P TERM_VCM VSS nfet_06v0 ad=5.2p pd=20.52u as=5.2p ps=20.52u w=20u l=0.7u
X99 FS_N_OUT LS_SLOW_B LSM_H_N FS_N_WELL pfet_06v0 ad=1.76p pd=8.88u as=1.76p ps=8.88u w=4u l=0.55u
X100 PULLUP_P_WELL PULLUP_P_GATE PULLUP_P_OUT PULLUP_P_WELL pfet_03v3 ad=8.8p pd=40.88u as=5.2p ps=20.52u w=20u l=0.28u
X101 FS_P_BLEED_2 FS_P_BLEED_3 VSS ppolyf_u_1k r_width=1u r_length=12.5u
X102 TERM_VCM TERM_GATE_P TERM_P_R VSS nfet_06v0 ad=5.2p pd=20.52u as=5.2p ps=20.52u w=20u l=0.7u
X103 FS_N_WELL FS_N_GATE FS_N_OUT FS_N_WELL pfet_06v0 ad=3.64p pd=14.52u as=3.64p ps=14.52u w=14u l=0.55u
X104 FS_N_OUT FS_N_GATE FS_N_WELL FS_N_WELL pfet_06v0 ad=3.64p pd=14.52u as=3.64p ps=14.52u w=14u l=0.55u
X105 TERM_GATE_N TERM_OR_N_B TERM_LS_N_S VDD pfet_03v3 ad=3.52p pd=16.88u as=3.52p ps=16.88u w=8u l=0.28u
X106 HS_P_3 HS_PBIAS VDD VDD pfet_03v3 ad=8.8p pd=40.88u as=8.8p ps=40.88u w=20u l=1u
X107 FS_N_WELL FS_N_GATE FS_N_OUT FS_N_WELL pfet_06v0 ad=3.64p pd=14.52u as=3.64p ps=14.52u w=14u l=0.55u
D6 VSS FS_LOW_N diode_nd2ps_03v3 pj=5.56u area=1.9321p
X108 HS_P_5 HS_PBIAS VDD VDD pfet_03v3 ad=8.8p pd=40.88u as=8.8p ps=40.88u w=20u l=1u
D7 PAD_P DVDD diode_pd2nw_06v0 pj=51.8u area=22.5p
X109 PULLUP_N_BLEED_2 PULLUP_N_BLEED_3 VSS ppolyf_u_1k r_width=1u r_length=12.5u
X110 FS_P_OUT FS_P_GATE FS_P_WELL FS_P_WELL pfet_06v0 ad=3.64p pd=14.52u as=6.16p ps=28.88u w=14u l=0.55u
X111 FS_P_GATE FS_HIGH_P FS_P_WELL FS_P_WELL pfet_06v0 ad=7.04p pd=32.88u as=7.04p ps=32.88u w=16u l=0.55u
X112 TERM_P_R TERM_GATE_P TERM_VCM VSS nfet_06v0 ad=5.2p pd=20.52u as=5.2p ps=20.52u w=20u l=0.7u
X113 FS_P_WELL FS_P_GATE FS_P_OUT FS_P_WELL pfet_06v0 ad=3.64p pd=14.52u as=3.64p ps=14.52u w=14u l=0.55u
X114 FS_P_WELL FS_P_GATE VDD FS_P_WELL pfet_06v0 ad=3.64p pd=14.52u as=3.64p ps=14.52u w=14u l=0.55u
X115 TERM_N_R LS_SLOW LSM_L_N VSS nfet_06v0 ad=1.76p pd=8.88u as=1.76p ps=8.88u w=4u l=0.7u
X116 FS_P_OUT FS_P_GATE FS_P_WELL FS_P_WELL pfet_06v0 ad=3.64p pd=14.52u as=3.64p ps=14.52u w=14u l=0.55u
X117 VDD FS_P_GATE FS_P_WELL FS_P_WELL pfet_06v0 ad=3.64p pd=14.52u as=3.64p ps=14.52u w=14u l=0.55u
D8 VSS PAD_P diode_nd2ps_06v0 pj=51.8u area=22.5p
X118 FS_N_WELL FS_N_BLEED_0 VSS ppolyf_u_1k r_width=1u r_length=12.5u
X119 HS_N_4 HS_PBIAS VDD VDD pfet_03v3 ad=8.8p pd=40.88u as=8.8p ps=40.88u w=20u l=1u
X120 PULLUP_P_WELL PULLUP_P_GATE VDD PULLUP_P_WELL pfet_06v0 ad=8.8p pd=40.88u as=5.2p ps=20.52u w=20u l=0.55u
D9 VSS PAD_P diode_nd2ps_06v0 pj=51.8u area=22.5p
D10 PAD_N DVDD diode_pd2nw_06v0 pj=51.8u area=22.5p
D11 PAD_P DVDD diode_pd2nw_06v0 pj=51.8u area=22.5p
D12 VSS PULLUP_P diode_nd2ps_03v3 pj=7.16u area=3.2041p
X121 TERM_GATE_P_BLEED_4 TERM_GATE_P_BLEED_5 VSS ppolyf_u_1k r_width=1u r_length=12.5u
X122 HS_N_6 HS_PBIAS VDD VDD pfet_03v3 ad=8.8p pd=40.88u as=8.8p ps=40.88u w=20u l=1u
X123 PULLUP_P_OUT PULLUP_P_GATE PULLUP_P_WELL PULLUP_P_WELL pfet_03v3 ad=5.2p pd=20.52u as=8.8p ps=40.88u w=20u l=0.28u
X124 TRIM_N_2_R PAD_N VSS ppolyf_u r_width=16u r_length=1.2u
X125 HS_P_13 HS_P PAD_P VSS nfet_06v0 ad=8.8p pd=40.88u as=8.8p ps=40.88u w=20u l=0.7u
X126 HS_P_8 HS_P PAD_P VSS nfet_06v0 ad=8.8p pd=40.88u as=8.8p ps=40.88u w=20u l=0.7u
X127 TRIM_N_0_R TERM_TRIM0 TERM_VCM VSS nfet_06v0 ad=2.2p pd=10.88u as=2.2p ps=10.88u w=5u l=0.7u
X128 HS_N_0 HS_PBIAS VDD VDD pfet_03v3 ad=8.8p pd=40.88u as=8.8p ps=40.88u w=20u l=1u
X129 PULLUP_P_GATE VDD PULLUP_P_WELL PULLUP_P_WELL pfet_06v0 ad=1.76p pd=8.88u as=1.76p ps=8.88u w=4u l=0.55u
X130 TERM_GATE_P_BLEED_0 TERM_GATE_P_BLEED_1 VSS ppolyf_u_1k r_width=1u r_length=12.5u
X131 HS_P_9 HS_P PAD_P VSS nfet_06v0 ad=8.8p pd=40.88u as=8.8p ps=40.88u w=20u l=0.7u
X132 HS_P_0 HS_P PAD_P VSS nfet_06v0 ad=8.8p pd=40.88u as=8.8p ps=40.88u w=20u l=0.7u
X133 LS_SLOW_B LS_SLOW VDD VDD pfet_03v3 ad=1.76p pd=8.88u as=1.76p ps=8.88u w=4u l=0.28u
X134 TERM_GATE_N TERM_OR_N_B VSS VSS nfet_03v3 ad=1.76p pd=8.88u as=1.76p ps=8.88u w=4u l=0.28u
X135 PAD_N PULLDOWN_N_R VSS ppolyf_u_1k r_width=1u r_length=14.2u
X136 TERM_LS_N_S HS_PBIAS VDD VDD pfet_03v3 ad=0.352p pd=2.48u as=0.352p ps=2.48u w=0.8u l=1u
X137 TERM_OR_P_B FS_LOW_P TERM_OR_P_S VDD pfet_03v3 ad=2.7808p pd=13.52u as=2.7808p ps=13.52u w=6.32u l=0.28u
X138 VDD FS_N_GATE FS_N_WELL FS_N_WELL pfet_06v0 ad=3.64p pd=14.52u as=3.64p ps=14.52u w=14u l=0.55u
X139 HS_P_6 HS_P PAD_P VSS nfet_06v0 ad=8.8p pd=40.88u as=8.8p ps=40.88u w=20u l=0.7u
X140 PAD_N BYPASS_ENABLE RX_N VSS nfet_06v0 ad=5.2p pd=20.52u as=8.8p ps=40.88u w=20u l=0.7u
X141 TERM_GATE_N TERM_GATE_N_BLEED_0 VSS ppolyf_u_1k r_width=1u r_length=12.5u
X142 FS_N_OUT FS_N_GATE FS_N_WELL FS_N_WELL pfet_06v0 ad=3.64p pd=14.52u as=3.64p ps=14.52u w=14u l=0.55u
X143 TERM_GATE_N_BLEED_1 TERM_GATE_N_BLEED_2 VSS ppolyf_u_1k r_width=1u r_length=12.5u
X144 TERM_GATE_P TERM_OR_P_B TERM_LS_P_S VDD pfet_03v3 ad=3.52p pd=16.88u as=3.52p ps=16.88u w=8u l=0.28u
X145 VDD FS_P_GATE FS_P_WELL FS_P_WELL pfet_06v0 ad=3.64p pd=14.52u as=3.64p ps=14.52u w=14u l=0.55u
X146 FS_P_WELL FS_P_GATE VDD FS_P_WELL pfet_06v0 ad=3.64p pd=14.52u as=3.64p ps=14.52u w=14u l=0.55u
X147 FS_N_WELL FS_N_GATE FS_N_OUT FS_N_WELL pfet_06v0 ad=3.64p pd=14.52u as=3.64p ps=14.52u w=14u l=0.55u
X148 TERM_VCM TERM_GATE_N TERM_N_R VSS nfet_06v0 ad=8.8p pd=40.88u as=5.2p ps=20.52u w=20u l=0.7u
X149 HS_P_2 HS_P PAD_P VSS nfet_06v0 ad=8.8p pd=40.88u as=8.8p ps=40.88u w=20u l=0.7u
X150 FS_P_WELL FS_P_GATE VDD FS_P_WELL pfet_06v0 ad=3.64p pd=14.52u as=3.64p ps=14.52u w=14u l=0.55u
D13 VSS TERM_TRIM0 diode_nd2ps_03v3 pj=5.28u area=1.7424p
X151 HS_N_0 HS_N PAD_N VSS nfet_06v0 ad=8.8p pd=40.88u as=8.8p ps=40.88u w=20u l=0.7u
X152 FS_P_OUT FS_P_GATE FS_P_WELL FS_P_WELL pfet_06v0 ad=3.64p pd=14.52u as=3.64p ps=14.52u w=14u l=0.55u
X153 TERM_OR_N_B VCM_LOW_OK TERM_OR_N_S VDD pfet_03v3 ad=2.7808p pd=13.52u as=2.7808p ps=13.52u w=6.32u l=0.28u
X154 FS_P_OUT LS_SLOW_B LSM_H_P FS_P_WELL pfet_06v0 ad=1.76p pd=8.88u as=1.76p ps=8.88u w=4u l=0.55u
X155 FS_P_WELL FS_P_GATE FS_P_OUT FS_P_WELL pfet_06v0 ad=3.64p pd=14.52u as=3.64p ps=14.52u w=14u l=0.55u
X156 FS_P_WELL FS_P_GATE FS_P_OUT FS_P_WELL pfet_06v0 ad=3.64p pd=14.52u as=3.64p ps=14.52u w=14u l=0.55u
X157 RX_N BYPASS_ENABLE PAD_N VSS nfet_06v0 ad=8.8p pd=40.88u as=5.2p ps=20.52u w=20u l=0.7u
X158 VSS RX_P VSS ppolyf_u_1k_6p0 r_width=1u r_length=0.31954m
X159 TRIM_P_0_R TERM_TRIM0 TERM_VCM VSS nfet_06v0 ad=2.2p pd=10.88u as=2.2p ps=10.88u w=5u l=0.7u
X160 TERM_N_R TERM_GATE_N TERM_VCM VSS nfet_06v0 ad=5.2p pd=20.52u as=8.8p ps=40.88u w=20u l=0.7u
X161 PULLUP_P_BLEED_4 PULLUP_P_BLEED_5 VSS ppolyf_u_1k r_width=1u r_length=12.5u
X162 PULLUP_P_BLEED_6 PULLUP_P_GATE VSS ppolyf_u_1k r_width=1u r_length=12.5u
X163 TERM_OR_N_B FS_LOW_N TERM_OR_N_NS VSS nfet_03v3 ad=1.3904p pd=7.2u as=1.3904p ps=7.2u w=3.16u l=0.28u
D14 VSS PULLUP_N diode_nd2ps_03v3 pj=4.88u area=1.4884p
X164 TERM_P_R DIFF_ENABLE TERM_N_R VSS nfet_06v0 ad=8.8p pd=40.88u as=8.8p ps=40.88u w=20u l=0.7u
X165 FS_N_BLEED_2 FS_N_BLEED_3 VSS ppolyf_u_1k r_width=1u r_length=12.5u
X166 LSNB LSNB VSS VSS nfet_03v3 ad=1.76p pd=8.88u as=1.76p ps=8.88u w=4u l=1u
D15 PAD_P DVDD diode_pd2nw_06v0 pj=51.8u area=22.5p
X167 VDD PULLUP_P_GATE PULLUP_P_WELL PULLUP_P_WELL pfet_06v0 ad=5.2p pd=20.52u as=8.8p ps=40.88u w=20u l=0.55u
X168 HS_P_12 HS_PBIAS VDD VDD pfet_03v3 ad=8.8p pd=40.88u as=8.8p ps=40.88u w=20u l=1u
X169 VDD FS_P_GATE FS_P_WELL FS_P_WELL pfet_06v0 ad=3.64p pd=14.52u as=6.16p ps=28.88u w=14u l=0.55u
D16 VSS PAD_N diode_nd2ps_06v0 pj=51.8u area=22.5p
X170 FS_N_OUT PAD_N VSS ppolyf_s r_width=2u r_length=3.5u
X171 HS_N_9 HS_PBIAS VDD VDD pfet_03v3 ad=8.8p pd=40.88u as=8.8p ps=40.88u w=20u l=1u
X172 HS_P_2 HS_PBIAS VDD VDD pfet_03v3 ad=8.8p pd=40.88u as=8.8p ps=40.88u w=20u l=1u
X173 PULLUP_N_OUT PAD_N VSS ppolyf_u_1k r_width=1u r_length=1.18u
X174 VDD FS_N_GATE FS_N_WELL FS_N_WELL pfet_06v0 ad=3.64p pd=14.52u as=3.64p ps=14.52u w=14u l=0.55u
X175 VDD FS_N_GATE FS_N_WELL FS_N_WELL pfet_06v0 ad=3.64p pd=14.52u as=3.64p ps=14.52u w=14u l=0.55u
X176 TERM_N_R TERM_GATE_N TERM_VCM VSS nfet_06v0 ad=5.2p pd=20.52u as=5.2p ps=20.52u w=20u l=0.7u
X177 PULLUP_P_BLEED_0 PULLUP_P_BLEED_1 VSS ppolyf_u_1k r_width=1u r_length=12.5u
X178 FS_N_WELL FS_N_GATE VDD FS_N_WELL pfet_06v0 ad=3.64p pd=14.52u as=3.64p ps=14.52u w=14u l=0.55u
X179 VDD FS_N_GATE FS_N_WELL FS_N_WELL pfet_06v0 ad=3.64p pd=14.52u as=6.16p ps=28.88u w=14u l=0.55u
X180 PULLUP_N_BLEED_1 PULLUP_N_BLEED_2 VSS ppolyf_u_1k r_width=1u r_length=12.5u
X181 FS_P_BLEED_5 FS_P_BLEED_6 VSS ppolyf_u_1k r_width=1u r_length=12.5u
X182 HS_P_4 HS_PBIAS VDD VDD pfet_03v3 ad=8.8p pd=40.88u as=8.8p ps=40.88u w=20u l=1u
X183 FS_N_WELL FS_N_GATE VDD FS_N_WELL pfet_06v0 ad=3.64p pd=14.52u as=3.64p ps=14.52u w=14u l=0.55u
X184 FS_N_BLEED_6 FS_N_GATE VSS ppolyf_u_1k r_width=1u r_length=12.5u
X185 FS_P_OUT LS_SLOW LSM_H_P VSS nfet_06v0 ad=1.76p pd=8.88u as=1.76p ps=8.88u w=4u l=0.7u
X186 RX_P BYPASS_ENABLE PAD_P VSS nfet_06v0 ad=8.8p pd=40.88u as=5.2p ps=20.52u w=20u l=0.7u
X187 FS_P_WELL FS_P_GATE VDD FS_P_WELL pfet_06v0 ad=3.64p pd=14.52u as=3.64p ps=14.52u w=14u l=0.55u
D17 PAD_N DVDD diode_pd2nw_06v0 pj=51.8u area=22.5p
D18 PAD_P DVDD diode_pd2nw_06v0 pj=51.8u area=22.5p
X188 FS_N_OUT FS_N_GATE FS_N_WELL FS_N_WELL pfet_06v0 ad=3.64p pd=14.52u as=3.64p ps=14.52u w=14u l=0.55u
X189 FS_P_WELL FS_P_GATE VDD FS_P_WELL pfet_06v0 ad=3.64p pd=14.52u as=3.64p ps=14.52u w=14u l=0.55u
X190 FS_N_WELL FS_N_GATE FS_N_OUT FS_N_WELL pfet_06v0 ad=3.64p pd=14.52u as=3.64p ps=14.52u w=14u l=0.55u
X191 HS_N_13 HS_PBIAS VDD VDD pfet_03v3 ad=8.8p pd=40.88u as=8.8p ps=40.88u w=20u l=1u
X192 FS_P_WELL FS_P_GATE VDD FS_P_WELL pfet_06v0 ad=3.64p pd=14.52u as=3.64p ps=14.52u w=14u l=0.55u
X193 FS_P_WELL FS_P_GATE FS_P_OUT FS_P_WELL pfet_06v0 ad=3.64p pd=14.52u as=3.64p ps=14.52u w=14u l=0.55u
X194 TERM_LS_P_S LS_SLOW VDD VDD pfet_03v3 ad=3.52p pd=16.88u as=3.52p ps=16.88u w=8u l=0.28u
X195 FS_P_WELL FS_P_GATE FS_P_OUT FS_P_WELL pfet_06v0 ad=3.64p pd=14.52u as=3.64p ps=14.52u w=14u l=0.55u
X196 TERM_VCM TERM_GATE_P TERM_P_R VSS nfet_06v0 ad=5.2p pd=20.52u as=5.2p ps=20.52u w=20u l=0.7u
X197 FS_N_CONTROL_S LS_SLOW_B FS_N_CTLX VSS nfet_03v3 ad=7.04p pd=32.88u as=7.04p ps=32.88u w=16u l=0.28u
X198 TERM_OR_N_NS VCM_LOW_OK VSS VSS nfet_03v3 ad=2.7808p pd=13.52u as=2.7808p ps=13.52u w=6.32u l=0.28u
X199 VSS RX_N VSS ppolyf_u_1k_6p0 r_width=1u r_length=0.31954m
X200 FS_P_WELL FS_P_GATE FS_P_OUT FS_P_WELL pfet_06v0 ad=3.64p pd=14.52u as=3.64p ps=14.52u w=14u l=0.55u
X201 FS_P_OUT FS_P_GATE FS_P_WELL FS_P_WELL pfet_06v0 ad=3.64p pd=14.52u as=3.64p ps=14.52u w=14u l=0.55u
X202 TERM_P_R LS_SLOW_B LSM_L_P FS_P_WELL pfet_06v0 ad=1.76p pd=8.88u as=1.76p ps=8.88u w=4u l=0.55u
X203 PAD_N DIV_N VSS ppolyf_u_1k r_width=1u r_length=2u
X204 TERM_GATE_N_BLEED_4 TERM_GATE_N_BLEED_5 VSS ppolyf_u_1k r_width=1u r_length=12.5u
X205 FS_P_CONTROL_S LSNB FS_P_CTLX VSS nfet_03v3 ad=1.76p pd=8.88u as=1.76p ps=8.88u w=4u l=1u
X206 VSS VDD FS_N_CTLX VSS nfet_06v0 ad=7.04p pd=32.88u as=4.16p ps=16.52u w=16u l=0.7u
X207 HS_N_4 HS_N PAD_N VSS nfet_06v0 ad=8.8p pd=40.88u as=8.8p ps=40.88u w=20u l=0.7u
X208 HS_P_11 HS_P PAD_P VSS nfet_06v0 ad=8.8p pd=40.88u as=8.8p ps=40.88u w=20u l=0.7u
X209 VDD FS_P_GATE FS_P_WELL FS_P_WELL pfet_06v0 ad=3.64p pd=14.52u as=3.64p ps=14.52u w=14u l=0.55u
D19 PAD_N DVDD diode_pd2nw_06v0 pj=51.8u area=22.5p
X210 TERM_GATE_P TERM_GATE_P_BLEED_0 VSS ppolyf_u_1k r_width=1u r_length=12.5u
X211 VDD FS_N_GATE FS_N_WELL FS_N_WELL pfet_06v0 ad=3.64p pd=14.52u as=3.64p ps=14.52u w=14u l=0.55u
X212 TRIM_N_2_R TERM_TRIM2 TERM_VCM VSS nfet_06v0 ad=8.8p pd=40.88u as=8.8p ps=40.88u w=20u l=0.7u
X213 HS_N_13 HS_N PAD_N VSS nfet_06v0 ad=8.8p pd=40.88u as=8.8p ps=40.88u w=20u l=0.7u
X214 FS_N_WELL FS_N_GATE VDD FS_N_WELL pfet_06v0 ad=3.64p pd=14.52u as=3.64p ps=14.52u w=14u l=0.55u
X215 TERM_OR_P_S TERM_ENABLE VDD VDD pfet_03v3 ad=2.7808p pd=13.52u as=2.7808p ps=13.52u w=6.32u l=0.28u
X216 TRIM_P_1_R TERM_TRIM1 TERM_VCM VSS nfet_06v0 ad=4.4p pd=20.88u as=4.4p ps=20.88u w=10u l=0.7u
X217 HS_N_6 HS_N PAD_N VSS nfet_06v0 ad=8.8p pd=40.88u as=8.8p ps=40.88u w=20u l=0.7u
X218 TERM_P_R TERM_GATE_P TERM_VCM VSS nfet_06v0 ad=5.2p pd=20.52u as=5.2p ps=20.52u w=20u l=0.7u
X219 VDD FS_N_GATE FS_N_WELL FS_N_WELL pfet_06v0 ad=3.64p pd=14.52u as=3.64p ps=14.52u w=14u l=0.55u
X220 FS_N_CTLX VDD VSS VSS nfet_06v0 ad=4.16p pd=16.52u as=7.04p ps=32.88u w=16u l=0.7u
D20 PAD_N DVDD diode_pd2nw_06v0 pj=51.8u area=22.5p
X221 TRIM_N_1_R TERM_TRIM1 TERM_VCM VSS nfet_06v0 ad=4.4p pd=20.88u as=4.4p ps=20.88u w=10u l=0.7u
X222 TERM_VCM TERM_GATE_P TERM_P_R VSS nfet_06v0 ad=5.2p pd=20.52u as=5.2p ps=20.52u w=20u l=0.7u
X223 FS_N_OUT FS_N_GATE FS_N_WELL FS_N_WELL pfet_06v0 ad=3.64p pd=14.52u as=3.64p ps=14.52u w=14u l=0.55u
X224 FS_N_OUT FS_N_GATE FS_N_WELL FS_N_WELL pfet_06v0 ad=3.64p pd=14.52u as=3.64p ps=14.52u w=14u l=0.55u
X225 FS_N_WELL FS_N_GATE FS_N_OUT FS_N_WELL pfet_06v0 ad=3.64p pd=14.52u as=3.64p ps=14.52u w=14u l=0.55u
X226 FS_N_GATE FS_HIGH_N FS_N_CONTROL_S VSS nfet_06v0 ad=7.04p pd=32.88u as=7.04p ps=32.88u w=16u l=0.7u
X227 VDD FS_P_GATE FS_P_WELL FS_P_WELL pfet_06v0 ad=3.64p pd=14.52u as=3.64p ps=14.52u w=14u l=0.55u
X228 FS_N_OUT FS_N_GATE FS_N_WELL FS_N_WELL pfet_06v0 ad=3.64p pd=14.52u as=3.64p ps=14.52u w=14u l=0.55u
X229 FS_P_OUT FS_P_GATE FS_P_WELL FS_P_WELL pfet_06v0 ad=3.64p pd=14.52u as=3.64p ps=14.52u w=14u l=0.55u
X230 FS_N_BLEED_3 FS_N_BLEED_4 VSS ppolyf_u_1k r_width=1u r_length=12.5u
X231 HS_P_7 HS_PBIAS VDD VDD pfet_03v3 ad=8.8p pd=40.88u as=8.8p ps=40.88u w=20u l=1u
X232 FS_P_OUT FS_P_GATE FS_P_WELL FS_P_WELL pfet_06v0 ad=3.64p pd=14.52u as=3.64p ps=14.52u w=14u l=0.55u
X233 FS_P_WELL FS_P_GATE FS_P_OUT FS_P_WELL pfet_06v0 ad=3.64p pd=14.52u as=3.64p ps=14.52u w=14u l=0.55u
X234 PULLUP_N_BLEED_4 PULLUP_N_BLEED_5 VSS ppolyf_u_1k r_width=1u r_length=12.5u
X235 FS_N_GATE VDD FS_N_WELL FS_N_WELL pfet_06v0 ad=1.76p pd=8.88u as=1.76p ps=8.88u w=4u l=0.55u
X236 FS_P_WELL FS_P_GATE FS_P_OUT FS_P_WELL pfet_06v0 ad=3.64p pd=14.52u as=3.64p ps=14.52u w=14u l=0.55u
D21 PAD_P DVDD diode_pd2nw_06v0 pj=51.8u area=22.5p
X237 HS_N_10 HS_PBIAS VDD VDD pfet_03v3 ad=8.8p pd=40.88u as=8.8p ps=40.88u w=20u l=1u
X238 PULLUP_P_OUT PAD_P VSS ppolyf_u_1k r_width=1u r_length=1.18u
X239 HS_P_12 HS_P PAD_P VSS nfet_06v0 ad=8.8p pd=40.88u as=8.8p ps=40.88u w=20u l=0.7u
D22 VSS PAD_N diode_nd2ps_06v0 pj=51.8u area=22.5p
X240 FS_P_BLEED_0 FS_P_BLEED_1 VSS ppolyf_u_1k r_width=1u r_length=12.5u
X241 DIV_LOW_P DIV_ENABLE VSS VSS nfet_06v0 ad=8.8p pd=40.88u as=8.8p ps=40.88u w=20u l=0.7u
D23 VSS PAD_P diode_nd2ps_06v0 pj=51.8u area=22.5p
X242 TERM_P_R DIFF_ENABLE TERM_N_R VSS nfet_06v0 ad=8.8p pd=40.88u as=8.8p ps=40.88u w=20u l=0.7u
X243 PULLUP_N_GATE PULLUP_N PULLUP_N_CONTROL_S VSS nfet_06v0 ad=0.88p pd=4.88u as=0.88p ps=4.88u w=2u l=0.7u
X244 PULLUP_N_OUT PULLUP_N_GATE PULLUP_N_WELL PULLUP_N_WELL pfet_03v3 ad=5.2p pd=20.52u as=8.8p ps=40.88u w=20u l=0.28u
X245 TERM_OR_N_B TERM_ENABLE VSS VSS nfet_03v3 ad=1.3904p pd=7.2u as=1.3904p ps=7.2u w=3.16u l=0.28u
X246 HS_P_10 HS_P PAD_P VSS nfet_06v0 ad=8.8p pd=40.88u as=8.8p ps=40.88u w=20u l=0.7u
X247 PULLUP_N_OUT PULLUP_N_GATE PULLUP_N_WELL PULLUP_N_WELL pfet_03v3 ad=5.2p pd=20.52u as=8.8p ps=40.88u w=20u l=0.28u
X248 FS_N_BLEED_1 FS_N_BLEED_2 VSS ppolyf_u_1k r_width=1u r_length=12.5u
X249 PULLUP_P_WELL PULLUP_P_GATE VDD PULLUP_P_WELL pfet_06v0 ad=8.8p pd=40.88u as=5.2p ps=20.52u w=20u l=0.55u
X250 HS_P_11 HS_PBIAS VDD VDD pfet_03v3 ad=8.8p pd=40.88u as=8.8p ps=40.88u w=20u l=1u
X251 FS_P_WELL FS_P_GATE VDD FS_P_WELL pfet_06v0 ad=3.64p pd=14.52u as=3.64p ps=14.52u w=14u l=0.55u
X252 LSM_H_P FS_P_GATE cap_mim_2f0_m4m5_noshield c_width=27.4u c_length=27.4u
D24 PAD_P DVDD diode_pd2nw_06v0 pj=51.8u area=22.5p
X253 HS_N_8 HS_PBIAS VDD VDD pfet_03v3 ad=8.8p pd=40.88u as=8.8p ps=40.88u w=20u l=1u
X254 TERM_OR_N_B FS_LOW_N TERM_OR_N_S VDD pfet_03v3 ad=2.7808p pd=13.52u as=2.7808p ps=13.52u w=6.32u l=0.28u
X255 PULLUP_P_WELL PULLUP_P_BLEED_0 VSS ppolyf_u_1k r_width=1u r_length=12.5u
X256 VDD FS_N_GATE FS_N_WELL FS_N_WELL pfet_06v0 ad=3.64p pd=14.52u as=3.64p ps=14.52u w=14u l=0.55u
X257 FS_N_WELL FS_N_GATE VDD FS_N_WELL pfet_06v0 ad=3.64p pd=14.52u as=3.64p ps=14.52u w=14u l=0.55u
X258 FS_P_BLEED_4 FS_P_BLEED_5 VSS ppolyf_u_1k r_width=1u r_length=12.5u
X259 VSS VDD FS_P_CTLX VSS nfet_06v0 ad=7.04p pd=32.88u as=4.16p ps=16.52u w=16u l=0.7u
D25 PAD_P DVDD diode_pd2nw_06v0 pj=51.8u area=22.5p
X260 FS_N_WELL FS_N_GATE VDD FS_N_WELL pfet_06v0 ad=6.16p pd=28.88u as=3.64p ps=14.52u w=14u l=0.55u
X261 VDD FS_N_GATE FS_N_WELL FS_N_WELL pfet_06v0 ad=3.64p pd=14.52u as=3.64p ps=14.52u w=14u l=0.55u
X262 TRIM_P_2_R PAD_P VSS ppolyf_u r_width=16u r_length=1.2u
X263 FS_N_OUT FS_N_GATE FS_N_WELL FS_N_WELL pfet_06v0 ad=3.64p pd=14.52u as=3.64p ps=14.52u w=14u l=0.55u
X264 TRIM_N_1_R PAD_N VSS ppolyf_u r_width=8u r_length=1.2u
X265 TERM_VCM TERM_GATE_N TERM_N_R VSS nfet_06v0 ad=5.2p pd=20.52u as=5.2p ps=20.52u w=20u l=0.7u
X266 HS_N_2 HS_PBIAS VDD VDD pfet_03v3 ad=8.8p pd=40.88u as=8.8p ps=40.88u w=20u l=1u
X267 TERM_GATE_P_BLEED_2 TERM_GATE_P_BLEED_3 VSS ppolyf_u_1k r_width=1u r_length=12.5u
X268 FS_N_OUT FS_N_GATE FS_N_WELL FS_N_WELL pfet_06v0 ad=3.64p pd=14.52u as=6.16p ps=28.88u w=14u l=0.55u
X269 TERM_N_R TERM_GATE_N TERM_VCM VSS nfet_06v0 ad=5.2p pd=20.52u as=5.2p ps=20.52u w=20u l=0.7u
X270 TERM_GATE_N_BLEED_5 TERM_GATE_N_BLEED_6 VSS ppolyf_u_1k r_width=1u r_length=12.5u
X271 FS_P_CTLX VDD VSS VSS nfet_06v0 ad=4.16p pd=16.52u as=7.04p ps=32.88u w=16u l=0.7u
X272 PAD_P BYPASS_ENABLE RX_P VSS nfet_06v0 ad=5.2p pd=20.52u as=8.8p ps=40.88u w=20u l=0.7u
X273 TERM_P_R TERM_GATE_P TERM_VCM VSS nfet_06v0 ad=5.2p pd=20.52u as=8.8p ps=40.88u w=20u l=0.7u
X274 HS_P_4 HS_P PAD_P VSS nfet_06v0 ad=8.8p pd=40.88u as=8.8p ps=40.88u w=20u l=0.7u
X275 HS_P_7 HS_P PAD_P VSS nfet_06v0 ad=8.8p pd=40.88u as=8.8p ps=40.88u w=20u l=0.7u
X276 RX_N BYPASS_ENABLE PAD_N VSS nfet_06v0 ad=8.8p pd=40.88u as=5.2p ps=20.52u w=20u l=0.7u
X277 VDD FS_P_GATE FS_P_WELL FS_P_WELL pfet_06v0 ad=3.64p pd=14.52u as=3.64p ps=14.52u w=14u l=0.55u
X278 LSM_L_P TERM_GATE_P cap_mim_2f0_m4m5_noshield c_width=27.4u c_length=27.4u
X279 PULLDOWN_N_R PULLDOWN_N VSS VSS nfet_06v0 ad=3.52p pd=16.88u as=3.52p ps=16.88u w=8u l=0.7u
X280 PULLUP_N_BLEED_0 PULLUP_N_BLEED_1 VSS ppolyf_u_1k r_width=1u r_length=12.5u
X281 FS_N_BLEED_5 FS_N_BLEED_6 VSS ppolyf_u_1k r_width=1u r_length=12.5u
X282 DIV_P DIV_LOW_P VSS ppolyf_u_1k r_width=1u r_length=2u
X283 TERM_GATE_N_BLEED_3 TERM_GATE_N_BLEED_4 VSS ppolyf_u_1k r_width=1u r_length=12.5u
X284 HS_P_3 HS_P PAD_P VSS nfet_06v0 ad=8.8p pd=40.88u as=8.8p ps=40.88u w=20u l=0.7u
X285 FS_P_OUT FS_P_GATE FS_P_WELL FS_P_WELL pfet_06v0 ad=3.64p pd=14.52u as=3.64p ps=14.52u w=14u l=0.55u
X286 HS_N_12 HS_PBIAS VDD VDD pfet_03v3 ad=8.8p pd=40.88u as=8.8p ps=40.88u w=20u l=1u
X287 TERM_VCM TERM_GATE_P TERM_P_R VSS nfet_06v0 ad=8.8p pd=40.88u as=5.2p ps=20.52u w=20u l=0.7u
X288 TERM_N_R TERM_GATE_N TERM_VCM VSS nfet_06v0 ad=5.2p pd=20.52u as=5.2p ps=20.52u w=20u l=0.7u
X289 FS_N_CONTROL_S LSNB FS_N_CTLX VSS nfet_03v3 ad=1.76p pd=8.88u as=1.76p ps=8.88u w=4u l=1u
D26 PAD_N DVDD diode_pd2nw_06v0 pj=51.8u area=22.5p
X290 TERM_GATE_P_BLEED_6 VSS VSS ppolyf_u_1k r_width=1u r_length=12.5u
X291 HS_N_2 HS_N PAD_N VSS nfet_06v0 ad=8.8p pd=40.88u as=8.8p ps=40.88u w=20u l=0.7u
X292 TERM_VCM TERM_GATE_N TERM_N_R VSS nfet_06v0 ad=5.2p pd=20.52u as=5.2p ps=20.52u w=20u l=0.7u
X293 VDD PULLUP_N_GATE PULLUP_N_WELL PULLUP_N_WELL pfet_06v0 ad=5.2p pd=20.52u as=8.8p ps=40.88u w=20u l=0.55u
X294 TERM_OR_P_B TERM_ENABLE VSS VSS nfet_03v3 ad=1.3904p pd=7.2u as=1.3904p ps=7.2u w=3.16u l=0.28u
X295 HS_N_11 HS_N PAD_N VSS nfet_06v0 ad=8.8p pd=40.88u as=8.8p ps=40.88u w=20u l=0.7u
X296 TRIM_P_0_R PAD_P VSS ppolyf_u r_width=4u r_length=1.2u
X297 TERM_P_R DIFF_ENABLE TERM_N_R VSS nfet_06v0 ad=8.8p pd=40.88u as=8.8p ps=40.88u w=20u l=0.7u
X298 VDD PULLUP_N_GATE PULLUP_N_WELL PULLUP_N_WELL pfet_06v0 ad=5.2p pd=20.52u as=8.8p ps=40.88u w=20u l=0.55u
X299 PULLUP_P_CONTROL_S VDD VSS VSS nfet_06v0 ad=1.76p pd=8.88u as=1.76p ps=8.88u w=4u l=0.7u
X300 FS_P_GATE VDD FS_P_WELL FS_P_WELL pfet_06v0 ad=1.76p pd=8.88u as=1.76p ps=8.88u w=4u l=0.55u
X301 HS_P_8 HS_PBIAS VDD VDD pfet_03v3 ad=8.8p pd=40.88u as=8.8p ps=40.88u w=20u l=1u
X302 FS_P_WELL FS_P_GATE VDD FS_P_WELL pfet_06v0 ad=3.64p pd=14.52u as=3.64p ps=14.52u w=14u l=0.55u
X303 PULLUP_N_BLEED_5 PULLUP_N_BLEED_6 VSS ppolyf_u_1k r_width=1u r_length=12.5u
X304 FS_P_CONTROL_S LS_SLOW_B FS_P_CTLX VSS nfet_03v3 ad=7.04p pd=32.88u as=7.04p ps=32.88u w=16u l=0.28u
X305 LSM_L_N TERM_GATE_N cap_mim_2f0_m4m5_noshield c_width=27.4u c_length=27.4u
X306 FS_N_WELL FS_N_GATE VDD FS_N_WELL pfet_06v0 ad=3.64p pd=14.52u as=3.64p ps=14.52u w=14u l=0.55u
X307 FS_N_WELL FS_N_GATE FS_N_OUT FS_N_WELL pfet_06v0 ad=3.64p pd=14.52u as=3.64p ps=14.52u w=14u l=0.55u
X308 TRIM_N_0_R PAD_N VSS ppolyf_u r_width=4u r_length=1.2u
X309 TERM_OR_P_NS VCM_LOW_OK VSS VSS nfet_03v3 ad=2.7808p pd=13.52u as=2.7808p ps=13.52u w=6.32u l=0.28u
X310 VDD FS_N_GATE FS_N_WELL FS_N_WELL pfet_06v0 ad=3.64p pd=14.52u as=3.64p ps=14.52u w=14u l=0.55u
X311 FS_N_WELL FS_N_GATE VDD FS_N_WELL pfet_06v0 ad=3.64p pd=14.52u as=3.64p ps=14.52u w=14u l=0.55u
X312 FS_N_OUT FS_N_GATE FS_N_WELL FS_N_WELL pfet_06v0 ad=3.64p pd=14.52u as=3.64p ps=14.52u w=14u l=0.55u
X313 PULLUP_P_GATE PULLUP_P PULLUP_P_CONTROL_S VSS nfet_06v0 ad=0.88p pd=4.88u as=0.88p ps=4.88u w=2u l=0.7u
X314 FS_P_BLEED_1 FS_P_BLEED_2 VSS ppolyf_u_1k r_width=1u r_length=12.5u
D27 VSS PAD_N diode_nd2ps_06v0 pj=51.8u area=22.5p
X315 PULLUP_P_BLEED_2 PULLUP_P_BLEED_3 VSS ppolyf_u_1k r_width=1u r_length=12.5u
X316 PAD_P DIV_P VSS ppolyf_u_1k r_width=1u r_length=2u
X317 FS_P_OUT PAD_P VSS ppolyf_s r_width=2u r_length=3.5u
X318 VDD FS_P_GATE FS_P_WELL FS_P_WELL pfet_06v0 ad=3.64p pd=14.52u as=3.64p ps=14.52u w=14u l=0.55u
D28 VSS PAD_P diode_nd2ps_06v0 pj=51.8u area=22.5p
D29 PAD_N DVDD diode_pd2nw_06v0 pj=51.8u area=22.5p
X319 PULLUP_N_BLEED_3 PULLUP_N_BLEED_4 VSS ppolyf_u_1k r_width=1u r_length=12.5u
X320 FS_N_OUT LS_SLOW LSM_H_N VSS nfet_06v0 ad=1.76p pd=8.88u as=1.76p ps=8.88u w=4u l=0.7u
X321 HS_P_6 HS_PBIAS VDD VDD pfet_03v3 ad=8.8p pd=40.88u as=8.8p ps=40.88u w=20u l=1u
X322 TERM_P_R TERM_GATE_P TERM_VCM VSS nfet_06v0 ad=5.2p pd=20.52u as=5.2p ps=20.52u w=20u l=0.7u
X323 VDD FS_P_GATE FS_P_WELL FS_P_WELL pfet_06v0 ad=3.64p pd=14.52u as=3.64p ps=14.52u w=14u l=0.55u
X324 HS_P_5 HS_P PAD_P VSS nfet_06v0 ad=8.8p pd=40.88u as=8.8p ps=40.88u w=20u l=0.7u
X325 FS_P_WELL FS_P_GATE VDD FS_P_WELL pfet_06v0 ad=3.64p pd=14.52u as=3.64p ps=14.52u w=14u l=0.55u
X326 PULLUP_P_OUT PULLUP_P_GATE PULLUP_P_WELL PULLUP_P_WELL pfet_03v3 ad=5.2p pd=20.52u as=8.8p ps=40.88u w=20u l=0.28u
X327 FS_P_WELL FS_P_BLEED_0 VSS ppolyf_u_1k r_width=1u r_length=12.5u
X328 FS_P_OUT FS_P_GATE FS_P_WELL FS_P_WELL pfet_06v0 ad=3.64p pd=14.52u as=3.64p ps=14.52u w=14u l=0.55u
D30 VSS TERM_ENABLE diode_nd2ps_03v3 pj=5.2u area=1.69p
X329 HS_P_0 HS_PBIAS VDD VDD pfet_03v3 ad=8.8p pd=40.88u as=8.8p ps=40.88u w=20u l=1u
X330 FS_P_WELL FS_P_GATE FS_P_OUT FS_P_WELL pfet_06v0 ad=3.64p pd=14.52u as=3.64p ps=14.52u w=14u l=0.55u
D31 VSS FS_LOW_P diode_nd2ps_03v3 pj=7.64u area=3.6481p
X331 HS_N_3 HS_PBIAS VDD VDD pfet_03v3 ad=8.8p pd=40.88u as=8.8p ps=40.88u w=20u l=1u
X332 TERM_GATE_P_BLEED_3 TERM_GATE_P_BLEED_4 VSS ppolyf_u_1k r_width=1u r_length=12.5u
X333 TERM_GATE_P TERM_OR_P_B VSS VSS nfet_03v3 ad=1.76p pd=8.88u as=1.76p ps=8.88u w=4u l=0.28u
X334 LS_SLOW_B LS_SLOW VSS VSS nfet_03v3 ad=0.88p pd=4.88u as=0.88p ps=4.88u w=2u l=0.28u
X335 HS_N_1 HS_N PAD_N VSS nfet_06v0 ad=8.8p pd=40.88u as=8.8p ps=40.88u w=20u l=0.7u
X336 TERM_OR_N_S TERM_ENABLE VDD VDD pfet_03v3 ad=2.7808p pd=13.52u as=2.7808p ps=13.52u w=6.32u l=0.28u
X337 HS_N_12 HS_N PAD_N VSS nfet_06v0 ad=8.8p pd=40.88u as=8.8p ps=40.88u w=20u l=0.7u
X338 DIV_N DIV_ENABLE RX_N VSS nfet_06v0 ad=8.8p pd=40.88u as=8.8p ps=40.88u w=20u l=0.7u
C0 TERM_VCM TERM_OR_P_NS 0.67024f
C1 HS_P_7 HS_P_13 0.06639f
C2 TERM_VCM FS_P_BLEED_3 0.05225f
C3 TERM_LS_N_S HS_N_9 0.01002f
C4 TERM_GATE_N_BLEED_1 LSNB 0.05271f
C5 TERM_OR_P_S FS_P_WELL 0.05597f
C6 HS_P_10 HS_N_4 0.02846f
C7 TERM_VCM PULLUP_P_WELL 0.07853f
C8 TERM_GATE_N TERM_OR_N_B 4.88803f
C9 PULLUP_P_WELL FS_P_WELL 0.00533f
C10 DIV_ENABLE HS_P_0 0.04269f
C11 BYPASS_ENABLE RX_P 2.669f
C12 TERM_ENABLE PULLUP_P_BLEED_3 0.00311f
C13 TERM_GATE_N_BLEED_1 FS_LOW_N 0.07069f
C14 PULLUP_P_BLEED_1 PULLUP_P_WELL 0.00421f
C15 HS_N HS_P_4 0.41846f
C16 PULLUP_P_OUT TERM_P_R 0.14359f
C17 PULLUP_P FS_LOW_N 0.04739f
C18 TERM_ENABLE TERM_P_R 0.14555f
C19 HS_P_0 TERM_N_R 0.04795f
C20 LS_SLOW LSM_L_P 0.52765f
C21 FS_LOW_P FS_N_BLEED_6 0.06271f
C22 RX_N DIFF_ENABLE 0.0964f
C23 TERM_TRIM2 PULLUP_N_OUT 0.02404f
C24 HS_N HS_P_9 0.42433f
C25 HS_N_5 FS_P_BLEED_0 0
C26 HS_P_7 HS_P_3 0.0312f
C27 FS_N_GATE FS_N_CTLX 0.32747f
C28 HS_PBIAS HS_N_4 7.22929f
C29 HS_P_6 HS_N_5 0.02404f
C30 DIV_P FS_P_WELL 0.04933f
C31 FS_P_BLEED_0 FS_P_BLEED_1 0.42584f
C32 HS_N_6 HS_P 0.27158f
C33 PULLDOWN_P_R PULLUP_P_OUT 0.03708f
C34 DIV_LOW_N PULLUP_N_OUT 0.05399f
C35 PULLDOWN_P_R TERM_ENABLE 0.04857f
C36 HS_P_2 FS_N_OUT 0.04828f
C37 HS_P_0 HS_N_8 0.03754f
C38 HS_N_4 HS_N_11 0
C39 HS_P_5 HS_N_0 0.02689f
C40 PAD_N HS_N_6 1.75716f
C41 TERM_TRIM2 HS_P_10 0.02846f
C42 FS_P_OUT PULLUP_N_OUT 9.59388f
C43 TERM_GATE_P TERM_P_R 11.7533f
C44 HS_P_8 FS_N_WELL 0.09346f
C45 HS_N_12 TERM_P_R 0.04383f
C46 LSM_L_P LS_SLOW_B 1.66449f
C47 PULLUP_P_BLEED_0 HS_N_11 0
C48 HS_P_4 HS_N_1 0.03489f
C49 HS_N_2 HS_P_2 0.04771f
C50 RX_P FS_P_CONTROL_S 0.03089f
C51 HS_N TERM_GATE_P_BLEED_1 0.05372f
C52 HS_P_1 HS_N_2 0.09696f
C53 HS_P_4 FS_P_GATE 0.03141f
C54 PULLDOWN_P_R TERM_GATE_P 0.05236f
C55 LS_SLOW FS_P_CONTROL_S 0.04428f
C56 HS_P_9 HS_N_1 0.03425f
C57 HS_N_9 TERM_GATE_P_BLEED_6 0.03489f
C58 HS_P_4 HS_P_12 0.03898f
C59 HS_P_11 HS_P_6 0.07974f
C60 FS_P_WELL HS_N_13 0.14504f
C61 PULLDOWN_P_R HS_N_12 0.02924f
C62 HS_P_9 FS_P_GATE 0.0373f
C63 PULLUP_N_GATE PULLUP_N_CONTROL_S 0.25995f
C64 FS_N_BLEED_6 FS_N_GATE 5.07886f
C65 HS_P_10 FS_P_OUT 0.07611f
C66 TERM_GATE_N_BLEED_3 HS_N_6 0.04809f
C67 FS_N_OUT PULLDOWN_P 0.10744f
C68 FS_P_BLEED_5 HS_N_12 0
C69 TERM_TRIM1 HS_N_9 0.03095f
C70 HS_P_6 HS_P_13 0.15266f
C71 HS_P_12 HS_P_9 0.03867f
C72 RX_N TERM_VCM 0.06959f
C73 TERM_GATE_P_BLEED_2 TERM_P_R 0.06848f
C74 TERM_TRIM1 LSM_H_P 0.04182f
C75 PULLUP_P_GATE PULLUP_P_BLEED_3 0.01215f
C76 RX_N FS_P_WELL 0.156f
C77 TERM_TRIM2 HS_PBIAS 0.30278f
C78 HS_N HS_N_3 0.82256f
C79 DIV_ENABLE HS_N_4 0.03489f
C80 PULLUP_P_BLEED_1 HS_N_13 0.03939f
C81 TERM_GATE_P_BLEED_3 TERM_P_R 0.04401f
C82 RX_N TERM_GATE_N_BLEED_5 0.0213f
C83 RX_N PULLUP_N_BLEED_5 0.02276f
C84 BYPASS_ENABLE FS_HIGH_N 0
C85 TERM_TRIM0 HS_P_5 0.04428f
C86 HS_PBIAS DIV_LOW_N 0.06823f
C87 PULLUP_P_GATE TERM_P_R 0.11492f
C88 VDD TERM_VCM 95.8809f
C89 HS_N_2 PULLDOWN_P 0.05914f
C90 PULLDOWN_P_R TERM_GATE_P_BLEED_2 0.11369f
C91 TERM_TRIM2 HS_N_11 0.17123f
C92 DIV_ENABLE PULLUP_P_BLEED_0 0
C93 PULLUP_P_BLEED_6 HS_N_10 0.03489f
C94 VCM_LOW_OK HS_P_2 0.09813f
C95 LSNB FS_N_OUT 82.65189f
C96 VDD FS_P_WELL 71.5081f
C97 HS_P_1 VCM_LOW_OK 0.14221f
C98 FS_P_CONTROL_S LS_SLOW_B 4.69496f
C99 TERM_GATE_P_BLEED_4 TERM_GATE_P_BLEED_6 0.23498f
C100 LSM_L_P HS_P_3 0
C101 PULLUP_N_BLEED_6 RX_N 0.08487f
C102 HS_N_0 DIV_LOW_P 0.0299f
C103 TERM_P_R PAD_P 3.28304f
C104 HS_P_5 DIV_LOW_P 0.00136f
C105 HS_PBIAS FS_P_OUT 0.30138f
C106 PULLDOWN_P_R TERM_GATE_P_BLEED_3 0.00488f
C107 TERM_N_R HS_N_4 0.09679f
C108 TERM_GATE_P_BLEED_1 HS_N_1 0.04023f
C109 VDD TERM_GATE_N_BLEED_5 0
C110 DIFF_ENABLE HS_P 0.1651f
C111 DIV_LOW_N HS_N_11 0.03894f
C112 TERM_TRIM1 TERM_GATE_P_BLEED_4 0.01496f
C113 PULLUP_P_GATE PULLDOWN_P_R 4.09173f
C114 BYPASS_ENABLE PULLUP_N_GATE 0
C115 LSM_H_N PULLDOWN_P 0.07003f
C116 HS_P_6 HS_P_3 0.05935f
C117 FS_LOW_N FS_N_OUT 0.10868f
C118 PULLUP_P_BLEED_6 FS_N_WELL 0.06807f
C119 HS_P_12 TERM_GATE_P_BLEED_1 0.00639f
C120 TERM_VCM TRIM_N_0_R 0.70262f
C121 PULLUP_P_GATE FS_P_BLEED_5 0
C122 PULLDOWN_P_R HS_N_7 0.02943f
C123 HS_N_2 LSNB 0.04604f
C124 FS_P_OUT HS_N_11 0.04032f
C125 FS_P_BLEED_6 HS_N_3 0.04301f
C126 FS_P_BLEED_4 LSNB 0.05271f
C127 PULLDOWN_P_R PAD_P 1.33498f
C128 HS_N_8 HS_N_4 0.04079f
C129 PULLUP_N_BLEED_6 VDD 0.00251f
C130 FS_N_OUT TERM_OR_P_B 0.0217f
C131 HS_P_10 PULLUP_N_OUT 0.05271f
C132 HS_N_1 HS_N_3 0.09292f
C133 PULLUP_P_BLEED_2 VCM_LOW_OK 0.85312f
C134 FS_P_GATE HS_N_3 0.074f
C135 FS_LOW_P HS_P_7 0.04566f
C136 VCM_LOW_OK PULLDOWN_P 0.03365f
C137 HS_P_12 HS_N_3 0.02404f
C138 HS_N_5 HS_N_6 84.3231f
C139 FS_LOW_N HS_N_2 0.08963f
C140 TERM_TRIM2 DIV_ENABLE 0.03667f
C141 TERM_TRIM1 TRIM_N_2_R 0
C142 HS_N_2 TERM_OR_P_B 0.0316f
C143 HS_N HS_P_8 0.1856f
C144 DIV_P HS_P_9 0.03388f
C145 TERM_OR_N_B PULLDOWN_P 1.41316f
C146 DIV_ENABLE DIV_LOW_N 0.39631f
C147 PULLUP_P_BLEED_3 PULLDOWN_N_R 0.00251f
C148 TERM_OR_N_S HS_N_3 0.02404f
C149 TERM_TRIM2 TERM_N_R 0.41001f
C150 VCM_LOW_OK LSNB 0.09457f
C151 HS_PBIAS PULLUP_N_OUT 0.7359f
C152 VDD FS_N_BLEED_5 0.82675f
C153 DIV_ENABLE FS_P_OUT 0.0855f
C154 PULLUP_N_WELL PULLUP_N_BLEED_1 0.75393f
C155 TERM_ENABLE FS_N_CONTROL_S 0.01083f
C156 TERM_VCM HS_P 0.00165f
C157 PULLDOWN_N_R TERM_P_R 0.0489f
C158 FS_P_WELL HS_P 0.35507f
C159 TERM_OR_P_S HS_N_3 0.04306f
C160 HS_N_3 PULLUP_P_WELL 0.15486f
C161 LSNB TERM_OR_N_B 0.06154f
C162 DIV_LOW_N TERM_N_R 1.56293f
C163 HS_P_11 HS_N_6 0.03489f
C164 HS_N_11 PULLUP_N_OUT 0.05016f
C165 VCM_LOW_OK FS_LOW_N 0.22465f
C166 PAD_N TERM_VCM 7.02998f
C167 HS_P_4 HS_N_13 0.03489f
C168 PULLUP_P_BLEED_1 HS_P 0.11051f
C169 PAD_N FS_P_WELL 0.25629f
C170 FS_P_OUT TERM_N_R 0.03784f
C171 HS_PBIAS HS_P_10 10.9755f
C172 PULLDOWN_P_R PULLDOWN_N_R 20.9177f
C173 VCM_LOW_OK TERM_OR_P_B 7.72604f
C174 FS_N_BLEED_2 HS_P 0.00212f
C175 HS_P_9 HS_N_13 0.03425f
C176 FS_LOW_N TERM_OR_N_B 6.47379f
C177 RX_N HS_P_4 0.08135f
C178 HS_N_8 DIV_LOW_N 0.03894f
C179 PULLUP_P PULLUP_P_BLEED_3 0.82704f
C180 HS_N_4 LSM_L_N 0.00263f
C181 HS_P_8 FS_P_GATE 0.06378f
C182 RX_N HS_P_9 0.0348f
C183 TERM_ENABLE PULLUP_N_WELL 0.18245f
C184 HS_P_10 HS_N_11 0.11728f
C185 TERM_GATE_N HS_N_4 0.02404f
C186 HS_P_8 HS_P_12 0
C187 TERM_GATE_N_BLEED_1 TERM_P_R 0.05954f
C188 BYPASS_ENABLE DIV_N 2.10566f
C189 FS_P_OUT HS_N_8 0.0359f
C190 PULLUP_P_OUT HS_N_10 0.02545f
C191 TERM_ENABLE HS_N_10 0.04571f
C192 TERM_TRIM1 FS_N_BLEED_6 0.04133f
C193 VDD HS_P_4 4.70922f
C194 PULLUP_P TERM_P_R 0.06456f
C195 HS_N PULLUP_P_BLEED_6 0.04421f
C196 RX_P DIFF_ENABLE 0.01852f
C197 LS_SLOW DIFF_ENABLE 0.00896f
C198 VDD HS_P_9 6.32438f
C199 TERM_OR_N_NS PULLUP_N_OUT 0.05024f
C200 HS_P_5 HS_N_9 0.05493f
C201 PULLUP_P_OUT FS_N_WELL 17.2345f
C202 FS_LOW_P HS_P_6 0.04566f
C203 TERM_ENABLE FS_N_WELL 0.25607f
C204 HS_N_0 FS_HIGH_P 0.04454f
C205 TERM_GATE_P_BLEED_1 HS_N_13 0.03931f
C206 PULLUP_P_BLEED_5 PULLUP_P_BLEED_4 0.04635f
C207 HS_P_0 HS_P_2 0.07808f
C208 HS_P_1 HS_P_0 36.3687f
C209 HS_PBIAS HS_N_11 7.27821f
C210 TERM_GATE_N_BLEED_2 DIV_LOW_N 0
C211 TERM_GATE_P HS_N_10 0.04872f
C212 TERM_N_R PULLUP_N_OUT 0.1354f
C213 DIV_ENABLE HS_P_10 0.03046f
C214 HS_N_12 HS_N_10 0.09644f
C215 HS_N_3 HS_N_13 0.26586f
C216 TERM_TRIM2 LSM_L_N 0.04182f
C217 TERM_TRIM2 TERM_GATE_N 9.88296f
C218 TERM_GATE_P FS_N_WELL 0.10124f
C219 PULLUP_P_BLEED_6 HS_N_1 0.03489f
C220 RX_N HS_N_3 0.08407f
C221 HS_N_12 FS_N_WELL 0.05366f
C222 HS_P_10 TERM_N_R 0.06184f
C223 TERM_ENABLE FS_N_BLEED_3 0.00311f
C224 TERM_GATE_N DIV_LOW_N 0.92336f
C225 RX_P TERM_VCM 0.06959f
C226 TERM_VCM HS_N_5 0.03677f
C227 RX_P FS_P_WELL 0.18859f
C228 TERM_TRIM0 HS_N_9 0.04428f
C229 HS_N_5 FS_P_WELL 0.1386f
C230 LS_SLOW TERM_VCM 0.15176f
C231 TERM_TRIM0 LSM_H_P 0.05476f
C232 LS_SLOW FS_P_WELL 0.13688f
C233 DIV_ENABLE HS_PBIAS 0.11254f
C234 VDD HS_N_3 6.16885f
C235 HS_P_4 HS_P 3.42166f
C236 RX_P TERM_GATE_N_BLEED_5 0.00418f
C237 TERM_GATE_N FS_P_OUT 77.6979f
C238 RX_P PULLUP_N_BLEED_5 0.00391f
C239 HS_P_10 HS_N_8 0.03103f
C240 LS_SLOW TERM_GATE_N_BLEED_5 0
C241 HS_N_9 DIV_LOW_P 0.02862f
C242 LS_SLOW PULLUP_N_BLEED_5 0
C243 PULLUP_P_GATE HS_N_10 0.07273f
C244 PULLUP_P_BLEED_1 HS_N_5 0.0458f
C245 HS_N PULLUP_N_BLEED_1 0.0661f
C246 HS_P_9 HS_P 3.34559f
C247 PULLUP_P_BLEED_3 PULLUP_P_BLEED_4 0.03688f
C248 HS_N_7 HS_N_10 0.03511f
C249 TRIM_P_0_R TERM_VCM 0.70262f
C250 DIV_ENABLE HS_N_11 0.03489f
C251 PAD_N HS_P_4 1.52873f
C252 TERM_GATE_P_BLEED_3 FS_N_WELL 0.21014f
C253 HS_N_10 PAD_P 0.63244f
C254 PULLUP_N_BLEED_6 RX_P 0.0516f
C255 FS_N_BLEED_0 FS_N_BLEED_1 0.05305f
C256 HS_PBIAS TERM_N_R 1.29105f
C257 PULLUP_N_BLEED_6 LS_SLOW 0.12963f
C258 TERM_ENABLE PULLDOWN_N 0.03489f
C259 TERM_VCM TRIM_P_1_R 1.40602f
C260 FS_HIGH_N DIFF_ENABLE 0.25832f
C261 PAD_N HS_P_9 2.47776f
C262 PULLUP_P_BLEED_6 PULLUP_P_WELL 0.00637f
C263 PULLUP_P_GATE FS_N_WELL 0.11807f
C264 TERM_TRIM2 TERM_GATE_P_BLEED_5 0.06247f
C265 TERM_TRIM0 TERM_GATE_P_BLEED_4 0.03831f
C266 TERM_VCM LS_SLOW_B 0.16209f
C267 TERM_VCM HS_P_11 0.02905f
C268 FS_P_CONTROL_S FS_N_GATE 0.04275f
C269 LS_SLOW_B FS_P_WELL 1.69335f
C270 HS_P_11 FS_P_WELL 0.04122f
C271 FS_N_OUT TERM_P_R 0.07109f
C272 PULLDOWN_N_R FS_N_CONTROL_S 0.0426f
C273 FS_N_WELL PAD_P 0.41085f
C274 TERM_N_R HS_N_11 0.07026f
C275 HS_P_7 TERM_GATE_P_BLEED_6 0.03489f
C276 TERM_VCM HS_P_13 0.0242f
C277 TERM_VCM TRIM_N_1_R 1.40602f
C278 HS_PBIAS HS_N_8 1.15538f
C279 HS_N PULLUP_P_OUT 0.07556f
C280 HS_P_0 TERM_OR_P_B 0.0357f
C281 HS_P_2 HS_N_4 0.02404f
C282 HS_N TERM_ENABLE 0.04122f
C283 HS_P_1 HS_N_4 0.02846f
C284 RX_N HS_P_8 0.12266f
C285 TERM_GATE_P_BLEED_0 FS_P_WELL 0.01483f
C286 TERM_GATE_P_BLEED_1 HS_P 0.11051f
C287 PULLUP_P_OUT PULLUP_P_CONTROL_S 0.01158f
C288 PULLUP_N_OUT LSM_L_N 0.04449f
C289 PULLDOWN_P_R FS_N_OUT 0.04301f
C290 TERM_ENABLE PULLUP_P_CONTROL_S 0.04476f
C291 FS_LOW_P HS_N_6 0.17323f
C292 HS_N_2 TERM_P_R 0.13199f
C293 HS_N_8 HS_N_11 0.00904f
C294 FS_P_BLEED_5 FS_N_OUT 0.03623f
C295 TERM_TRIM2 FS_P_CTLX 0.03396f
C296 DIV_N HS_N_6 0.04579f
C297 FS_P_BLEED_4 TERM_P_R 0.04034f
C298 TERM_GATE_N PULLUP_N_OUT 0.91705f
C299 VDD HS_P_8 5.9782f
C300 HS_N_3 HS_P 0.20364f
C301 PULLUP_N_WELL PULLDOWN_N_R 0.14972f
C302 HS_N TERM_GATE_P 0.33913f
C303 PULLDOWN_P_R HS_N_2 0.02893f
C304 LSM_H_N TERM_P_R 2.41722f
C305 PULLDOWN_P_R FS_P_BLEED_4 0.05212f
C306 VCM_LOW_OK PULLUP_P_BLEED_3 0.05027f
C307 HS_N HS_N_12 2.6021f
C308 DIV_ENABLE TERM_N_R 0.07993f
C309 TERM_VCM HS_P_3 0.06056f
C310 PULLUP_P FS_N_CONTROL_S 0.04494f
C311 HS_N_4 PULLDOWN_P 0.06583f
C312 HS_N_10 PULLDOWN_N_R 0.06864f
C313 TERM_OR_N_NS TERM_N_R 0.043f
C314 TERM_GATE_N HS_P_10 0.05493f
C315 TERM_VCM FS_HIGH_N 0.03195f
C316 FS_P_BLEED_4 FS_P_BLEED_5 0.96553f
C317 PAD_N HS_N_3 1.61089f
C318 TERM_VCM PULLUP_N_BLEED_0 0.84592f
C319 PULLUP_P_OUT HS_N_1 0.02599f
C320 TERM_ENABLE HS_N_1 0.03489f
C321 PULLUP_P_OUT FS_P_GATE 0.05506f
C322 HS_PBIAS PULLUP_N_BLEED_4 0.01803f
C323 TERM_ENABLE FS_P_GATE 0.08361f
C324 VCM_LOW_OK TERM_P_R 58.0118f
C325 LS_SLOW_B FS_N_BLEED_5 0.00265f
C326 DIV_ENABLE HS_N_8 0.03782f
C327 TERM_TRIM2 HS_P_2 0.07949f
C328 TERM_ENABLE HS_P_12 0.03489f
C329 PULLDOWN_N_R FS_N_WELL 0.10035f
C330 TERM_TRIM2 HS_P_1 0.09292f
C331 TERM_GATE_N_BLEED_2 HS_N_11 0
C332 PULLUP_P_BLEED_6 HS_N_13 0.03489f
C333 BYPASS_ENABLE TERM_GATE_P_BLEED_6 0.00766f
C334 FS_N_BLEED_0 FS_HIGH_P 0.01347f
C335 RX_P HS_P_4 0.0416f
C336 LSNB HS_N_4 0.04524f
C337 PULLUP_N_GATE TERM_VCM 0.07522f
C338 HS_P_4 HS_N_5 0.13672f
C339 TERM_OR_N_B TERM_P_R 0.08392f
C340 RX_N PULLUP_P_BLEED_6 0.05598f
C341 TERM_GATE_N_BLEED_3 HS_N_3 0.04313f
C342 HS_PBIAS LSM_L_N 0.53629f
C343 PULLDOWN_P_R VCM_LOW_OK 0.07906f
C344 RX_P HS_P_9 0.02846f
C345 HS_N_5 HS_P_9 0.03425f
C346 VDD TERM_GATE_N_BLEED_4 0
C347 TERM_GATE_N_BLEED_1 HS_N_10 0.03931f
C348 PULLUP_P PULLUP_N_WELL 0.34376f
C349 TERM_ENABLE TERM_OR_N_S 1.75757f
C350 HS_PBIAS TERM_GATE_N 0.38985f
C351 LS_SLOW HS_P_9 0.03763f
C352 PULLUP_N_GATE PULLUP_N_BLEED_5 0.28431f
C353 FS_P_BLEED_6 HS_N_12 0.03973f
C354 TERM_GATE_P HS_N_1 0.08707f
C355 PULLUP_P_BLEED_0 LSNB 0.10225f
C356 HS_N_8 TERM_N_R 0.03095f
C357 FS_LOW_N HS_N_4 0.08963f
C358 HS_N PULLUP_P_GATE 0.11404f
C359 HS_P_2 FS_P_OUT 0.04021f
C360 TERM_TRIM1 LSM_L_P 0.03653f
C361 FS_P_GATE TERM_GATE_P 0.07246f
C362 PULLUP_P HS_N_10 0.0397f
C363 HS_P_1 FS_P_OUT 0.07368f
C364 HS_N_12 HS_N_1 0.06897f
C365 HS_N_11 LSM_L_N 0.0468f
C366 HS_N_12 FS_P_GATE 0.07519f
C367 TERM_TRIM0 FS_N_BLEED_6 0.05601f
C368 PULLDOWN_P_R TERM_OR_N_B 0.00133f
C369 HS_P_12 TERM_GATE_P 0.03931f
C370 HS_P_6 TERM_GATE_P_BLEED_6 0.03489f
C371 HS_N HS_N_7 1.21738f
C372 HS_N_9 FS_HIGH_P 0.04403f
C373 VDD PULLUP_P_BLEED_6 0.44981f
C374 FS_LOW_P DIFF_ENABLE 0.22748f
C375 HS_N_4 TERM_OR_P_B 0.03089f
C376 PULLUP_P_GATE PULLUP_P_CONTROL_S 0.58764f
C377 HS_N PAD_P 2.26447f
C378 TERM_GATE_N HS_N_11 0.05354f
C379 HS_P_12 HS_N_12 0.06338f
C380 TERM_OR_P_S TERM_ENABLE 1.66528f
C381 TERM_GATE_N_BLEED_1 FS_N_WELL 0.06656f
C382 PULLUP_N_GATE PULLUP_N_BLEED_6 0.90825f
C383 PULLUP_P_OUT PULLUP_P_WELL 12.3264f
C384 HS_P_8 HS_P 4.68997f
C385 TERM_ENABLE PULLUP_P_WELL 0.06271f
C386 PULLDOWN_N_R FS_N_BLEED_3 0.00251f
C387 PULLUP_P FS_N_WELL 0.39135f
C388 TERM_VCM FS_N_BLEED_4 0.00196f
C389 DIV_ENABLE TERM_GATE_N_BLEED_2 0
C390 HS_P_4 HS_P_11 0.03887f
C391 DIV_LOW_N PULLDOWN_P 0.3826f
C392 HS_N_12 TERM_OR_N_S 0.02404f
C393 PAD_N HS_P_8 2.86075f
C394 TERM_GATE_P_BLEED_2 FS_P_GATE 0.14164f
C395 HS_P_4 HS_P_13 0.35362f
C396 HS_P_9 LS_SLOW_B 0.05037f
C397 HS_P_11 HS_P_9 0.03867f
C398 TERM_GATE_P_BLEED_1 HS_N_5 0.0458f
C399 TERM_LS_N_S HS_N_6 0.00351f
C400 TERM_GATE_P_BLEED_2 HS_P_12 0.04425f
C401 TERM_TRIM2 LSNB 0.01805f
C402 TERM_GATE_P_BLEED_3 FS_P_GATE 0.01215f
C403 HS_P_9 HS_P_13 0.08736f
C404 PULLUP_P_GATE FS_P_BLEED_6 0
C405 TERM_OR_P_S HS_N_12 0.04174f
C406 FS_P_BLEED_6 HS_N_7 0.05112f
C407 PULLUP_P_GATE HS_N_1 0.07291f
C408 HS_N_12 PULLUP_P_WELL 0.16544f
C409 TERM_TRIM1 FS_P_CONTROL_S 0.05964f
C410 DIV_P TERM_ENABLE 0.02156f
C411 RX_P HS_N_3 0.03692f
C412 TERM_N_R PULLUP_N_BLEED_4 0.82106f
C413 LSNB DIV_LOW_N 0.05233f
C414 HS_N_1 HS_N_7 0.03226f
C415 DIV_ENABLE TERM_GATE_N 0.06178f
C416 HS_N_5 HS_N_3 0.04946f
C417 PULLDOWN_N PULLDOWN_N_R 5.89741f
C418 TERM_TRIM2 FS_LOW_N 0.02404f
C419 TERM_GATE_N TERM_OR_N_NS 0.64977f
C420 FS_P_GATE HS_N_7 0.07482f
C421 LS_SLOW HS_N_3 0.00299f
C422 HS_P_2 PULLUP_N_OUT 0.05271f
C423 HS_N_1 PAD_P 0.54342f
C424 PULLUP_P FS_N_BLEED_3 0.82704f
C425 FS_P_GATE PAD_P 27.9807f
C426 FS_N_BLEED_6 FS_N_BLEED_1 0.00257f
C427 HS_P_1 PULLUP_N_OUT 0.04585f
C428 FS_N_OUT FS_N_CONTROL_S 0.08506f
C429 HS_P_12 HS_N_7 0.06096f
C430 TERM_GATE_N_BLEED_4 HS_P 0.00212f
C431 FS_P_OUT LSNB 0.05356f
C432 TERM_TRIM2 TERM_OR_P_B 0.04174f
C433 HS_P_12 PAD_P 1.62323f
C434 RX_N PULLUP_N_BLEED_1 0.05718f
C435 FS_LOW_P TERM_VCM 0.06972f
C436 FS_LOW_N DIV_LOW_N 0.05113f
C437 TERM_N_R LSM_L_N 0.96042f
C438 FS_LOW_P FS_P_WELL 0.20715f
C439 HS_P_5 HS_P_7 0.00206f
C440 HS_P_11 TERM_GATE_P_BLEED_1 0.00863f
C441 HS_P_4 HS_P_3 33.6384f
C442 DIV_N TERM_VCM 0.0388f
C443 HS_N PULLDOWN_N_R 0.04222f
C444 DIV_N FS_P_WELL 0.1708f
C445 TERM_GATE_N TERM_N_R 14.7998f
C446 HS_PBIAS FS_P_CTLX 0
C447 HS_N_7 TERM_OR_N_S 0.02404f
C448 PULLUP_P_BLEED_6 HS_P 0.03489f
C449 DIV_P TERM_GATE_P 0.18819f
C450 HS_P_3 HS_P_9 0.08047f
C451 TERM_GATE_P_BLEED_1 HS_P_13 0
C452 HS_P_10 HS_P_2 0.03898f
C453 HS_P_1 HS_P_10 37.0303f
C454 DIV_N TERM_GATE_N_BLEED_5 0.13115f
C455 DIV_P HS_N_12 0.03401f
C456 VDD PULLUP_N_BLEED_1 0.48141f
C457 TERM_GATE_P_BLEED_0 TERM_GATE_P_BLEED_1 0.10979f
C458 PULLUP_P_BLEED_2 PULLUP_N_OUT 0.09726f
C459 FS_N_BLEED_4 FS_N_BLEED_5 0.04635f
C460 PULLUP_P_OUT HS_N_13 0.02464f
C461 FS_P_OUT TERM_OR_P_B 0.12498f
C462 PULLUP_N_BLEED_2 FS_HIGH_P 0.01347f
C463 HS_P_11 HS_N_3 0.03489f
C464 TERM_ENABLE HS_N_13 0.03489f
C465 PULLUP_P_GATE PULLUP_P_WELL 20.8365f
C466 TERM_GATE_N HS_N_8 0.04847f
C467 PULLUP_N_OUT PULLDOWN_P 0.03494f
C468 TERM_OR_P_S HS_N_7 0.04587f
C469 PULLUP_P PULLDOWN_N 0.06167f
C470 HS_N_7 PULLUP_P_WELL 0.15846f
C471 RX_N PULLUP_P_OUT 17.1049f
C472 RX_N TERM_ENABLE 0.12537f
C473 TERM_GATE_N_BLEED_3 TERM_GATE_N_BLEED_4 0.034f
C474 HS_N_10 FS_N_OUT 0
C475 FS_N_BLEED_6 FS_N_BLEED_0 0.00257f
C476 TERM_GATE_N_BLEED_1 HS_N 0.04864f
C477 HS_P_0 TERM_P_R 0.08029f
C478 TERM_GATE_P_BLEED_6 HS_N_6 0.03489f
C479 PULLUP_P_BLEED_4 FS_N_WELL 0.02521f
C480 HS_PBIAS HS_P_2 6.38284f
C481 VDD PULLUP_P_OUT 2.87909f
C482 RX_P HS_P_8 0.08258f
C483 HS_P_1 HS_PBIAS 4.77315f
C484 HS_N_1 PULLDOWN_N_R 0.02445f
C485 TERM_VCM FS_N_GATE 5.01764f
C486 LSNB PULLUP_N_OUT 0.06635f
C487 VDD TERM_ENABLE 10.5283f
C488 TERM_GATE_P_BLEED_1 HS_P_3 0
C489 TERM_GATE_P HS_N_13 0.03931f
C490 VDD TERM_GATE_N_BLEED_0 1.29083f
C491 FS_N_GATE FS_P_WELL 1.84016f
C492 FS_N_OUT FS_N_WELL 70.27721f
C493 LS_SLOW HS_P_8 0.00299f
C494 FS_P_GATE PULLDOWN_N_R 0.26922f
C495 PULLUP_P PULLUP_P_CONTROL_S 0.39497f
C496 HS_N_12 HS_N_13 98.98511f
C497 HS_N_2 HS_N_10 0
C498 PULLDOWN_P_R HS_P_0 0.0447f
C499 HS_P_12 PULLDOWN_N_R 0.02404f
C500 FS_P_BLEED_4 HS_N_10 0.03931f
C501 RX_N TERM_GATE_P 0.21067f
C502 TERM_GATE_N_BLEED_5 FS_N_GATE 0.05491f
C503 HS_P_2 HS_N_11 0.03425f
C504 BYPASS_ENABLE HS_N_0 0
C505 RX_N HS_N_12 0.0418f
C506 HS_P_7 DIV_LOW_P 0
C507 FS_LOW_N PULLUP_N_OUT 0.05379f
C508 PULLUP_N_WELL LSM_H_N 0.04333f
C509 TERM_VCM TERM_GATE_N_BLEED_6 0.00196f
C510 DIV_P PAD_P 1.17252f
C511 FS_N_GATE FS_N_BLEED_2 0
C512 FS_N_BLEED_6 FS_HIGH_P 0.09407f
C513 PULLUP_N_OUT TERM_OR_P_B 0.14459f
C514 HS_N_2 FS_N_WELL 0.05123f
C515 TERM_OR_N_S PULLDOWN_N_R 0.03743f
C516 FS_P_BLEED_4 FS_N_WELL 0.0635f
C517 PULLUP_P_BLEED_2 HS_PBIAS 0.01803f
C518 TERM_GATE_N_BLEED_5 TERM_GATE_N_BLEED_6 0.03688f
C519 VDD TERM_GATE_P 2.36967f
C520 HS_PBIAS PULLDOWN_P 0.46091f
C521 TERM_GATE_N_BLEED_1 HS_N_1 0.03931f
C522 VDD HS_N_12 5.59345f
C523 PULLUP_N_BLEED_1 HS_P 0.05271f
C524 FS_P_BLEED_2 FS_N_WELL 0.00856f
C525 HS_P_6 HS_N_0 0.02686f
C526 HS_P_5 HS_P_6 32.3301f
C527 LSM_H_N FS_N_WELL 2.20433f
C528 VCM_LOW_OK HS_N_10 0.02404f
C529 TERM_GATE_N LSM_L_N 3.8124f
C530 PULLDOWN_N_R PULLUP_P_WELL 0.34342f
C531 HS_P_8 HS_P_13 0.05624f
C532 HS_N_5 TERM_GATE_N_BLEED_4 0
C533 TERM_VCM TERM_LS_P_S 0.08754f
C534 HS_P_10 TERM_OR_P_B 0.06233f
C535 HS_N_11 PULLDOWN_P 0.06607f
C536 PULLUP_P_GATE HS_N_13 0.07211f
C537 RX_N TERM_GATE_P_BLEED_3 0.00885f
C538 DIV_ENABLE HS_P_2 0.00336f
C539 HS_N_7 HS_N_13 0.10643f
C540 DIV_ENABLE HS_P_1 0.09846f
C541 PULLUP_P_BLEED_5 TERM_TRIM2 0.06247f
C542 HS_PBIAS LSNB 2.20033f
C543 HS_N_10 TERM_OR_N_B 0.05855f
C544 RX_N PULLUP_P_GATE 0.11417f
C545 HS_N_13 PAD_P 0.08298f
C546 VDD TERM_GATE_P_BLEED_2 0
C547 FS_LOW_P HS_P_4 0.17315f
C548 RX_P PULLUP_P_BLEED_6 0.04507f
C549 VCM_LOW_OK FS_N_WELL 0.12634f
C550 PULLUP_P_BLEED_6 HS_N_5 0.03489f
C551 FS_N_GATE FS_N_BLEED_5 0
C552 DIV_N HS_P_4 0.01203f
C553 LS_SLOW PULLUP_P_BLEED_6 0.05817f
C554 PULLUP_P_OUT HS_P 0.02404f
C555 PULLUP_P TERM_OR_N_S 0.04801f
C556 VDD TERM_GATE_P_BLEED_3 0
C557 TERM_ENABLE HS_P 0.03677f
C558 RX_N PAD_P 0.80789f
C559 FS_LOW_P HS_P_9 0.05657f
C560 LSNB HS_N_11 0.04757f
C561 DIV_N HS_P_9 0
C562 HS_PBIAS FS_LOW_N 0.3994f
C563 HS_P_2 TERM_N_R 0.03089f
C564 HS_N_4 TERM_P_R 0.13362f
C565 TERM_OR_N_B FS_N_WELL 0.05407f
C566 TERM_TRIM0 LSM_L_P 0.07134f
C567 VDD PULLUP_P_GATE 9.42654f
C568 HS_P_1 TERM_N_R 0.05692f
C569 LSM_H_N FS_N_BLEED_3 0.00165f
C570 VDD HS_N_7 5.51774f
C571 HS_PBIAS TERM_OR_P_B 0.40472f
C572 HS_P_8 HS_P_3 0.03109f
C573 VDD PAD_P 0.93129f
C574 PULLUP_P PULLUP_P_WELL 0.09299f
C575 FS_LOW_N HS_N_11 0.08963f
C576 TERM_OR_N_NS PULLDOWN_P 0.01383f
C577 HS_P_2 HS_N_8 0.03089f
C578 PULLDOWN_P_R HS_N_4 0.02846f
C579 TRIM_P_2_R TERM_P_R 0.0574f
C580 HS_P_1 HS_N_8 0.03109f
C581 HS_N FS_N_OUT 10.9245f
C582 TERM_GATE_P HS_P 0.3329f
C583 HS_N_11 TERM_OR_P_B 0.03248f
C584 PULLUP_P_BLEED_6 LS_SLOW_B 0.07012f
C585 HS_N_12 HS_P 0.1715f
C586 HS_P_6 DIV_LOW_P 0.00103f
C587 PULLUP_P_BLEED_2 TERM_N_R 0.08788f
C588 TERM_N_R PULLDOWN_P 4.74382f
C589 HS_P_4 FS_N_GATE 0.0359f
C590 PAD_N TERM_GATE_P 1.03455f
C591 DIV_ENABLE LSNB 0.04426f
C592 PAD_N HS_N_12 1.55524f
C593 HS_N HS_N_2 8.48796f
C594 PULLDOWN_N_R HS_N_13 0.02404f
C595 HS_P_9 FS_N_GATE 0.04275f
C596 HS_N FS_P_BLEED_4 0.04565f
C597 PULLUP_P_BLEED_2 HS_N_8 0.00108f
C598 TERM_TRIM0 FS_P_CONTROL_S 0.08812f
C599 TERM_VCM TERM_GATE_P_BLEED_6 0.04678f
C600 FS_LOW_P HS_N_3 0.04574f
C601 PULLUP_N_BLEED_2 PULLUP_N_BLEED_3 0.05994f
C602 TERM_GATE_P_BLEED_2 HS_P 0.00212f
C603 RX_N PULLDOWN_N_R 0.04428f
C604 TERM_GATE_P_BLEED_6 FS_P_WELL 0.04122f
C605 TERM_TRIM2 TERM_P_R 0.08715f
C606 HS_N_8 PULLDOWN_P 0.02404f
C607 HS_P_7 HS_N_9 0.03738f
C608 DIV_ENABLE FS_LOW_N 0.12944f
C609 DIV_N HS_N_3 0.04536f
C610 FS_LOW_N TERM_OR_N_NS 0.27419f
C611 TERM_TRIM1 TERM_VCM 8.17925f
C612 FS_P_BLEED_6 FS_N_OUT 0.10652f
C613 LSNB TERM_N_R 0.10048f
C614 RX_P PULLUP_N_BLEED_1 0.04379f
C615 HS_N LSM_H_N 0.06141f
C616 TERM_TRIM1 FS_P_WELL 0.09351f
C617 LS_SLOW PULLUP_N_BLEED_1 0.05718f
C618 HS_N_1 FS_N_OUT 0
C619 DIV_LOW_N TERM_P_R 0.04869f
C620 HS_N_12 TERM_GATE_N_BLEED_3 0.03976f
C621 FS_P_GATE FS_N_OUT 0.11785f
C622 PULLUP_P_GATE HS_P 0.0773f
C623 HS_N_0 HS_N_6 0.04236f
C624 HS_P_5 HS_N_6 0.02404f
C625 VDD PULLDOWN_N_R 2.09852f
C626 HS_P_12 FS_N_OUT 0.07916f
C627 HS_N_7 HS_P 0.44537f
C628 FS_LOW_N TERM_N_R 0.15744f
C629 HS_N_8 LSNB 0.04524f
C630 FS_P_OUT TERM_P_R 0.0247f
C631 TERM_GATE_N_BLEED_1 HS_N_13 0.03931f
C632 HS_P PAD_P 40.9693f
C633 HS_N VCM_LOW_OK 0.03336f
C634 FS_P_BLEED_6 HS_N_2 0.03931f
C635 FS_P_BLEED_6 FS_P_BLEED_4 0.00131f
C636 TERM_N_R TERM_OR_P_B 0.11166f
C637 HS_N_2 HS_N_1 0.29096f
C638 PULLUP_N_BLEED_6 TERM_TRIM1 0.01462f
C639 TERM_GATE_N_BLEED_1 RX_N 0.0547f
C640 FS_P_BLEED_4 HS_N_1 0.03931f
C641 HS_N_2 FS_P_GATE 0.1037f
C642 PAD_N HS_N_7 1.25996f
C643 TERM_OR_N_S FS_N_OUT 0.03336f
C644 FS_P_BLEED_4 FS_P_GATE 0.04869f
C645 RX_P PULLUP_P_OUT 0.00199f
C646 TERM_GATE_N HS_P_2 0.03089f
C647 PULLUP_P_OUT HS_N_5 0.02404f
C648 HS_N TERM_OR_N_B 0.07735f
C649 PAD_N PAD_P 34.353f
C650 FS_LOW_N HS_N_8 0.08963f
C651 RX_P TERM_ENABLE 0.16929p
C652 PULLDOWN_P_R FS_P_OUT 0
C653 HS_P_1 TERM_GATE_N 0.0525f
C654 RX_N PULLUP_P 0.0321f
C655 HS_P_12 HS_N_2 0.0554f
C656 TERM_ENABLE HS_N_5 0.06622f
C657 LS_SLOW PULLUP_P_OUT 0.04477f
C658 LS_SLOW TERM_ENABLE 0.16949p
C659 PULLUP_P_OUT FS_P_BLEED_1 0.04959f
C660 HS_P_0 HS_N_10 0.10644f
C661 HS_N_3 FS_N_GATE 0.04522f
C662 HS_N_8 TERM_OR_P_B 0.03122f
C663 TERM_ENABLE FS_P_BLEED_1 0.00311f
C664 PULLUP_N_BLEED_4 PULLDOWN_P 0.087f
C665 TERM_GATE_N_BLEED_1 VDD 0.51228f
C666 TERM_OR_P_S FS_N_OUT 0.0659f
C667 FS_P_BLEED_2 FS_P_GATE 0
C668 PULLUP_P_WELL FS_N_OUT 0.29947f
C669 HS_N_2 TERM_OR_N_S 0.02404f
C670 PULLUP_N PULLUP_N_CONTROL_S 2.33602f
C671 VDD PULLUP_P 1.07159f
C672 TERM_GATE_N_BLEED_3 HS_N_7 0.05151f
C673 FS_LOW_P HS_P_8 0.04566f
C674 PULLUP_P_BLEED_3 PULLUP_N_OUT 0.05139f
C675 BYPASS_ENABLE FS_HIGH_P 0
C676 LSM_L_N PULLDOWN_P 0.02004f
C677 TERM_GATE_N_BLEED_2 LSNB 0.10193f
C678 RX_P TERM_GATE_P 0.19209f
C679 TERM_TRIM1 FS_N_BLEED_5 0.12457f
C680 HS_N_5 TERM_GATE_P 0.09149f
C681 VCM_LOW_OK HS_N_1 0.02404f
C682 LS_SLOW TERM_GATE_P 0.0572f
C683 TERM_GATE_N PULLDOWN_P 0.06672f
C684 RX_P HS_N_12 0.03089f
C685 VCM_LOW_OK FS_P_GATE 0.17493f
C686 TERM_OR_P_S HS_N_2 0.04174f
C687 HS_N_12 HS_N_5 0
C688 LSM_L_P LSM_H_P 0.04519f
C689 FS_P_BLEED_4 FS_P_BLEED_3 1.73155f
C690 PULLUP_P_OUT LS_SLOW_B 0.02594f
C691 PULLUP_N_OUT TERM_P_R 2.71584f
C692 LS_SLOW HS_N_12 0.0418f
C693 HS_N_6 DIV_LOW_P 0.02846f
C694 HS_N_2 PULLUP_P_WELL 0.15404f
C695 TERM_ENABLE LS_SLOW_B 0.20181f
C696 VCM_LOW_OK HS_P_12 0.08704f
C697 HS_P_11 TERM_ENABLE 0.03489f
C698 TERM_GATE_N_BLEED_0 LS_SLOW_B 0.00229f
C699 FS_P_BLEED_4 PULLUP_P_WELL 0.00106f
C700 FS_P_BLEED_0 HS_N_9 0.00148f
C701 HS_N_1 TERM_OR_N_B 0.05861f
C702 FS_LOW_N TERM_GATE_N_BLEED_2 0.0839f
C703 PULLDOWN_N_R HS_P 0.03308f
C704 TERM_ENABLE HS_P_13 0.03489f
C705 HS_P_6 HS_N_9 0.03117f
C706 FS_P_BLEED_2 FS_P_BLEED_3 0.11149f
C707 DIV_P FS_N_OUT 0.06353f
C708 FS_HIGH_N PULLUP_N_BLEED_1 0.16603f
C709 PULLDOWN_P_R PULLUP_N_OUT 0.03494f
C710 VCM_LOW_OK TERM_OR_N_S 5.5254f
C711 TERM_LS_N_S HS_N_3 0.00153f
C712 PULLUP_N_BLEED_0 PULLUP_N_BLEED_1 1.41012f
C713 TERM_GATE_N LSNB 0.04793f
C714 PAD_N PULLDOWN_N_R 2.76468f
C715 TERM_GATE_P_BLEED_2 HS_N_5 0
C716 HS_P_10 TERM_P_R 0.07501f
C717 HS_P_11 TERM_GATE_P 0.09149f
C718 TERM_GATE_P LS_SLOW_B 0.06714f
C719 RX_P TERM_GATE_P_BLEED_3 0.00418f
C720 HS_P_4 TERM_GATE_P_BLEED_6 0.03489f
C721 TERM_OR_N_S TERM_OR_N_B 1.61419f
C722 VCM_LOW_OK TERM_OR_P_NS 1.97012f
C723 HS_N_12 LS_SLOW_B 0.05569f
C724 HS_P_11 HS_N_12 0.03489f
C725 TERM_OR_P_S VCM_LOW_OK 0.07956f
C726 LS_SLOW TERM_GATE_P_BLEED_3 0
C727 HS_P_8 FS_N_GATE 0.07622f
C728 DIV_N TERM_GATE_N_BLEED_4 0.03851f
C729 TERM_GATE_N FS_LOW_N 0.04106f
C730 HS_P_13 TERM_GATE_P 0.04872f
C731 HS_P_9 TERM_GATE_P_BLEED_6 0.0458f
C732 VCM_LOW_OK PULLUP_P_WELL 5.61364f
C733 RX_P PULLUP_P_GATE 0.08944f
C734 PULLUP_N_GATE PULLUP_N_BLEED_1 0.08183f
C735 PULLUP_P_GATE HS_N_5 0.0733f
C736 TERM_GATE_N_BLEED_1 HS_P 0.03931f
C737 PULLDOWN_P_R HS_P_10 0.0832f
C738 LS_SLOW PULLUP_P_GATE 0.05505f
C739 TERM_GATE_P_BLEED_0 TERM_GATE_P 0.96553f
C740 HS_N_5 HS_N_7 0.04397f
C741 FS_LOW_P PULLUP_P_BLEED_6 0.06866f
C742 TERM_GATE_N TERM_OR_P_B 0.09678f
C743 TERM_TRIM1 HS_P_9 0.04506f
C744 HS_P_3 PULLUP_P_OUT 0.04356f
C745 TERM_ENABLE HS_P_3 0.06578f
C746 FS_P_CONTROL_S FS_HIGH_P 0.55985f
C747 RX_P PAD_P 6.49815f
C748 TERM_GATE_P_BLEED_0 HS_N_12 0
C749 HS_N_5 PAD_P 1.41633f
C750 FS_HIGH_N TERM_ENABLE 0.02421f
C751 DIV_N PULLUP_P_BLEED_6 0.10151f
C752 FS_N_OUT HS_N_13 0.04421f
C753 HS_N_10 HS_N_4 0
C754 RX_N PULLUP_P_BLEED_4 0.08699f
C755 HS_PBIAS TERM_P_R 0.75418f
C756 TERM_GATE_P_BLEED_2 HS_P_11 0.04516f
C757 RX_N FS_N_OUT 0.04185f
C758 PULLUP_P_BLEED_0 HS_N_10 0
C759 TERM_GATE_P_BLEED_2 HS_P_13 0.03321f
C760 HS_P_5 TERM_VCM 0.02413f
C761 TRIM_P_0_R PAD_P 0.26208f
C762 HS_N_0 FS_P_WELL 0.4105f
C763 HS_N_11 TERM_P_R 0.08415f
C764 HS_P_5 FS_P_WELL 0.10211f
C765 HS_N_4 FS_N_WELL 0.05366f
C766 HS_N_2 HS_N_13 88.9959f
C767 PULLUP_N_GATE TERM_ENABLE 0.10244f
C768 VDD PULLUP_P_BLEED_4 0.00251f
C769 PULLDOWN_P_R HS_PBIAS 0.47205f
C770 PULLUP_P_GATE LS_SLOW_B 0.06302f
C771 TERM_GATE_P_BLEED_1 TERM_GATE_P_BLEED_6 0.00257f
C772 FS_P_BLEED_4 HS_N_13 0.03931f
C773 HS_P_3 TERM_GATE_P 0.04226f
C774 HS_P_1 HS_P_2 0.07746f
C775 PAD_P TRIM_P_1_R 0.52916f
C776 VDD FS_N_OUT 3.86604f
C777 HS_N HS_P_0 0.52781f
C778 TERM_GATE_N_BLEED_1 TERM_GATE_N_BLEED_3 0.00131f
C779 HS_P_11 HS_N_7 0.10095f
C780 RX_N HS_N_2 0.03937f
C781 RX_N FS_P_BLEED_4 0.05141f
C782 HS_P_11 PAD_P 1.45755f
C783 PULLUP_P_BLEED_1 HS_N_0 0.0408f
C784 PULLDOWN_P_R HS_N_11 0.0295f
C785 HS_P_13 HS_N_7 0.00553f
C786 HS_P_13 PAD_P 1.31839f
C787 FS_P_BLEED_5 HS_N_11 0
C788 TERM_GATE_P_BLEED_6 HS_N_3 0.03489f
C789 PULLUP_P_BLEED_6 FS_N_GATE 0.05717f
C790 FS_P_CTLX LSNB 0.43883f
C791 TERM_TRIM2 PULLUP_N_WELL 0.21225f
C792 RX_N FS_P_BLEED_2 0.08699f
C793 TRIM_N_0_R FS_N_OUT 0.01632f
C794 VDD HS_N_2 6.36006f
C795 RX_N LSM_H_N 0.05272f
C796 VDD FS_P_BLEED_4 0.41574f
C797 TERM_GATE_P_BLEED_2 HS_P_3 0.03192f
C798 RX_P PULLDOWN_N_R 0.03089f
C799 HS_N_5 PULLDOWN_N_R 0.06832f
C800 TERM_ENABLE FS_N_BLEED_4 0.0503f
C801 VCM_LOW_OK HS_N_13 0.02404f
C802 DIV_ENABLE TERM_P_R 0.0855f
C803 BYPASS_ENABLE FS_N_BLEED_6 0.00766f
C804 LS_SLOW PULLDOWN_N_R 0.09128f
C805 HS_N_9 HS_N_6 0.00106f
C806 TERM_OR_N_NS TERM_P_R 0.04001f
C807 FS_P_BLEED_1 PULLDOWN_N_R 0.00251f
C808 TERM_TRIM0 TERM_VCM 9.23036f
C809 VDD FS_P_BLEED_2 0.0049f
C810 PULLUP_P_BLEED_3 TERM_N_R 0.07622f
C811 FS_LOW_P PULLUP_N_BLEED_1 0.06271f
C812 HS_N_6 FS_HIGH_P 0.05527f
C813 DIV_LOW_N HS_N_10 0.03894f
C814 VDD LSM_H_N 0.58018f
C815 RX_N VCM_LOW_OK 0.08614f
C816 TERM_TRIM0 FS_P_WELL 0.10471f
C817 HS_P_0 HS_N_1 0.04356f
C818 TERM_OR_N_B HS_N_13 0.05828f
C819 TERM_TRIM2 FS_N_WELL 0.21071f
C820 HS_P_0 FS_P_GATE 0.03153f
C821 HS_P_3 HS_N_7 0.00259f
C822 HS_P_0 HS_P_12 0.06959f
C823 HS_P_3 PAD_P 1.40343f
C824 TERM_N_R TERM_P_R 0.15638p
C825 FS_P_WELL DIV_LOW_P 0.05607f
C826 RX_N TERM_OR_N_B 0.04317f
C827 DIV_ENABLE FS_P_BLEED_5 0
C828 DIV_LOW_N FS_N_WELL 0.05579f
C829 VDD VCM_LOW_OK 4.27362f
C830 TERM_GATE_N_BLEED_1 RX_P 0.04379f
C831 PULLUP_N_OUT FS_N_CONTROL_S 0.05105f
C832 TERM_GATE_N_BLEED_1 HS_N_5 0.03931f
C833 PULLUP_N_BLEED_6 TERM_TRIM0 0.03632f
C834 TERM_GATE_N_BLEED_1 LS_SLOW 0.05776f
C835 PULLDOWN_N_R LS_SLOW_B 0.04185f
C836 HS_P_11 PULLDOWN_N_R 0.02404f
C837 FS_N_OUT HS_P 0.36231f
C838 FS_P_OUT FS_N_WELL 0.05195f
C839 RX_P PULLUP_P 0.00665f
C840 PULLUP_P HS_N_5 0.04655f
C841 HS_N_8 TERM_P_R 0.04412f
C842 FS_LOW_P PULLUP_P_OUT 0.04493f
C843 PULLDOWN_P_R TERM_N_R 0.92353f
C844 VDD TERM_OR_N_B 4.05265f
C845 FS_LOW_P TERM_ENABLE 0.13723f
C846 LS_SLOW PULLUP_P 0.10537f
C847 HS_P_13 PULLDOWN_N_R 0.02404f
C848 DIV_N TERM_ENABLE 0.03543f
C849 HS_P_8 TERM_GATE_P_BLEED_6 0.03489f
C850 HS_P_2 TERM_OR_P_B 0.05742f
C851 PAD_N FS_N_OUT 1.28721f
C852 HS_P_1 TERM_OR_P_B 0.05237f
C853 HS_N HS_N_4 3.04971f
C854 TERM_OR_P_S HS_P_0 0.03062f
C855 TERM_TRIM1 HS_P_8 0.05414f
C856 HS_N_2 HS_P 0.92388f
C857 PULLDOWN_P_R HS_N_8 0.02975f
C858 FS_P_BLEED_4 HS_P 0.03931f
C859 LSNB PULLDOWN_P 0.06362f
C860 PULLUP_N_WELL PULLUP_N_OUT 15.3519f
C861 HS_N PULLUP_P_BLEED_0 0.00799f
C862 HS_P_5 HS_P_4 33.6991f
C863 HS_P_4 HS_N_0 0.03489f
C864 TERM_GATE_N_BLEED_1 LS_SLOW_B 0.07012f
C865 FS_LOW_P TERM_GATE_P 0.15612f
C866 TERM_TRIM0 FS_N_BLEED_5 0.02567f
C867 PAD_N HS_N_2 1.39681f
C868 HS_N_10 PULLUP_N_OUT 0.04331f
C869 TERM_GATE_N_BLEED_3 FS_N_OUT 0.85952f
C870 DIV_N TERM_GATE_P 0.14344f
C871 FS_LOW_P HS_N_12 0.04594f
C872 HS_P_9 HS_N_0 0.03425f
C873 LSM_H_N HS_P 0.06971f
C874 HS_P_5 HS_P_9 0.03898f
C875 PULLUP_P LS_SLOW_B 0.05249f
C876 FS_LOW_N PULLDOWN_P 0.13218f
C877 DIV_N HS_N_12 0.04579f
C878 FS_N_BLEED_2 FS_N_BLEED_1 0.034f
C879 DIFF_ENABLE FS_HIGH_P 0.20577f
C880 HS_P_3 PULLDOWN_N_R 0.07217f
C881 FS_HIGH_N PULLDOWN_N_R 0.05849f
C882 TERM_TRIM2 PULLDOWN_N 0.03489f
C883 HS_PBIAS FS_N_CONTROL_S 0.04214f
C884 PULLUP_P_OUT FS_N_GATE 0.10537f
C885 PULLUP_N_OUT FS_N_WELL 0.11383f
C886 PULLUP_N_BLEED_4 TERM_P_R 0.01212f
C887 FS_P_BLEED_6 HS_N_4 0.04405f
C888 TERM_ENABLE FS_N_GATE 0.19971f
C889 VCM_LOW_OK HS_P 0.02649f
C890 HS_P_10 HS_N_10 0.09066f
C891 HS_N_1 HS_N_4 0.0414f
C892 HS_N_2 TERM_GATE_N_BLEED_3 0.03931f
C893 TERM_GATE_N PULLUP_P_BLEED_3 0.83128f
C894 FS_P_GATE HS_N_4 0.10011f
C895 FS_LOW_N LSNB 0.11682f
C896 HS_P_12 HS_N_4 0.0525f
C897 HS_N TERM_TRIM2 0.14108f
C898 PULLUP_N_GATE PULLDOWN_N_R 1.19963f
C899 TERM_OR_N_B HS_P 0.06053f
C900 TERM_P_R LSM_L_N 0.04218f
C901 LSNB TERM_OR_P_B 0.00481f
C902 PULLUP_P_BLEED_0 HS_N_1 0
C903 TERM_ENABLE TERM_GATE_N_BLEED_6 0.04999f
C904 TERM_TRIM2 PULLUP_P_CONTROL_S 0.049f
C905 HS_P_10 FS_N_WELL 0.11229f
C906 TERM_GATE_N TERM_P_R 0.17599f
C907 TERM_GATE_P_BLEED_1 HS_N_0 0.04058f
C908 HS_P_5 TERM_GATE_P_BLEED_1 0
C909 FS_LOW_P PULLUP_P_GATE 0.1903f
C910 DIFF_ENABLE PULLUP_N 0.12118f
C911 TERM_TRIM1 PULLUP_P_BLEED_6 0.04303f
C912 HS_N DIV_LOW_N 0.04826f
C913 TERM_GATE_P FS_N_GATE 0.08902f
C914 HS_PBIAS PULLUP_N_WELL 0.15657f
C915 DIV_N PULLUP_P_GATE 0.00199f
C916 FS_LOW_P HS_N_7 0.04574f
C917 TERM_OR_N_S HS_N_4 0.02404f
C918 TERM_TRIM0 HS_P_9 0.03698f
C919 HS_N_12 FS_N_GATE 0.05207f
C920 PULLUP_P FS_HIGH_N 0.05995f
C921 PULLUP_N_OUT FS_N_BLEED_3 0.05203f
C922 DIV_N HS_N_7 0.04536f
C923 HS_P_0 HS_N_13 0.05273f
C924 HS_N FS_P_OUT 0.21539f
C925 HS_P_4 DIV_LOW_P 0.00346f
C926 RX_P PULLUP_P_BLEED_4 0.05373f
C927 HS_PBIAS HS_N_10 4.93897f
C928 DIV_N PAD_P 1.43881f
C929 TERM_VCM HS_N_9 0.00117f
C930 LS_SLOW PULLUP_P_BLEED_4 0.12973f
C931 HS_N_9 FS_P_WELL 0.15526f
C932 HS_N_3 HS_N_0 0.03213f
C933 HS_P_5 HS_N_3 0.02404f
C934 TERM_VCM LSM_H_P 0.04182f
C935 RX_P FS_N_OUT 0.09636f
C936 TERM_LS_P_S PULLUP_P_OUT 0.06461f
C937 LSM_H_P FS_P_WELL 1.32979f
C938 TERM_OR_P_S HS_N_4 0.04343f
C939 TERM_LS_P_S TERM_ENABLE 0.03795f
C940 HS_P_7 HS_P_6 31.6408f
C941 FS_P_WELL FS_HIGH_P 2.19017f
C942 TERM_LS_N_S TERM_ENABLE 0.01083f
C943 LS_SLOW FS_N_OUT 0.62595f
C944 PULLUP_P_WELL HS_N_4 0.15717f
C945 HS_N_10 HS_N_11 0.1013p
C946 PULLUP_P_BLEED_1 HS_N_9 0.06246f
C947 HS_PBIAS FS_N_WELL 0.92534f
C948 PULLUP_N_GATE PULLUP_P 1.49319f
C949 TERM_TRIM2 FS_P_GATE 0.14498f
C950 PULLUP_P_BLEED_0 PULLUP_P_WELL 0.97169f
C951 RX_P HS_N_2 0.04185f
C952 VDD HS_P_0 3.79766f
C953 HS_N_5 HS_N_2 0.04894f
C954 TERM_GATE_P_BLEED_3 FS_N_GATE 0.82412f
C955 RX_P FS_P_BLEED_4 0.04507f
C956 FS_P_BLEED_4 HS_N_5 0.03931f
C957 HS_N_1 DIV_LOW_N 0.03902f
C958 HS_N_11 FS_N_WELL 0.10488f
C959 LS_SLOW FS_P_BLEED_4 0.05817f
C960 TERM_N_R FS_N_CONTROL_S 2.00824f
C961 TERM_VCM TERM_GATE_P_BLEED_4 0.00196f
C962 PULLUP_P_GATE FS_N_GATE 0.09449f
C963 TERM_LS_P_S TERM_GATE_P 0.87397f
C964 FS_P_BLEED_4 FS_P_BLEED_1 0.07572f
C965 PULLUP_P_BLEED_4 LS_SLOW_B 0.23676f
C966 FS_P_OUT HS_N_1 0.0359f
C967 RX_P FS_P_BLEED_2 0.05373f
C968 HS_P_11 FS_N_OUT 0.03489f
C969 LS_SLOW_B FS_N_OUT 0.41139f
C970 TERM_TRIM2 TERM_OR_N_S 0.08172f
C971 FS_P_GATE FS_P_OUT 10.0388f
C972 RX_P LSM_H_N 0.04182f
C973 FS_N_GATE PAD_P 0.30975f
C974 DIV_ENABLE PULLUP_N_WELL 0.02656f
C975 LS_SLOW FS_P_BLEED_2 0.12973f
C976 LS_SLOW LSM_H_N 3.80316f
C977 FS_P_BLEED_2 FS_P_BLEED_1 0.03795f
C978 HS_N PULLUP_N_OUT 0.10986f
C979 DIV_ENABLE HS_N_10 0.03489f
C980 PULLUP_N PULLUP_N_BLEED_5 0.00878f
C981 FS_LOW_P PULLDOWN_N_R 0.0629f
C982 TERM_GATE_P_BLEED_0 FS_N_OUT 0.03623f
C983 TERM_TRIM2 TERM_OR_P_NS 0.03673f
C984 TERM_TRIM1 PULLUP_N_BLEED_1 0.04304f
C985 TERM_TRIM2 FS_P_BLEED_3 0.05904f
C986 DIV_N PULLDOWN_N_R 0.05876f
C987 RX_P VCM_LOW_OK 0.05113f
C988 HS_N_3 DIV_LOW_P 0.02846f
C989 TERM_TRIM2 PULLUP_P_WELL 0.06271f
C990 HS_P_11 HS_N_2 0.06578f
C991 VCM_LOW_OK HS_N_5 0.02445f
C992 TRIM_N_2_R TERM_VCM 2.65999f
C993 HS_P_5 HS_P_8 0.00106f
C994 FS_P_BLEED_4 LS_SLOW_B 0.06829f
C995 PULLUP_N_WELL TERM_N_R 0.15833f
C996 LS_SLOW VCM_LOW_OK 0.10557f
C997 VCM_LOW_OK FS_P_BLEED_1 0.05027f
C998 DIV_ENABLE FS_N_WELL 0.18475f
C999 HS_N_2 HS_P_13 0.04835f
C1000 TERM_OR_N_NS FS_N_WELL 0.05171f
C1001 HS_N HS_P_10 0.76302f
C1002 HS_N_10 TERM_N_R 0.09487f
C1003 RX_P TERM_OR_N_B 0.03226f
C1004 HS_N_5 TERM_OR_N_B 0.05869f
C1005 LS_SLOW TERM_OR_N_B 0.04428f
C1006 FS_P_BLEED_2 LS_SLOW_B 0.23603f
C1007 PULLUP_P_OUT TERM_GATE_P_BLEED_6 0.05654f
C1008 LSM_H_N LS_SLOW_B 2.09093f
C1009 HS_N_4 HS_N_13 0.14463f
C1010 TERM_ENABLE TERM_GATE_P_BLEED_6 0.04337f
C1011 TERM_GATE_N_BLEED_1 FS_LOW_P 0.06271f
C1012 TERM_LS_N_S HS_N_7 0.00491f
C1013 FS_HIGH_N FS_N_OUT 0.16909f
C1014 TERM_N_R FS_N_WELL 1.08584f
C1015 RX_N HS_N_4 0.03937f
C1016 HS_N_8 HS_N_10 0.04185f
C1017 HS_P_0 HS_P 10.1975f
C1018 TERM_TRIM1 TERM_GATE_N_BLEED_0 0.11331f
C1019 TERM_TRIM1 TERM_ENABLE 0.07874f
C1020 DIV_N TERM_GATE_N_BLEED_1 0.14002f
C1021 TERM_TRIM2 DIV_P 0.09345f
C1022 FS_P_GATE PULLUP_N_OUT 0.1303f
C1023 HS_P_2 TERM_P_R 0.03089f
C1024 HS_P_1 TERM_P_R 0.06878f
C1025 VCM_LOW_OK LS_SLOW_B 0.06928f
C1026 HS_P_11 VCM_LOW_OK 0.08844f
C1027 DIV_N PULLUP_P 0.04748f
C1028 PULLDOWN_N_R FS_N_GATE 0.07928f
C1029 PAD_N HS_P_0 0.38256f
C1030 HS_N HS_PBIAS 0.36394f
C1031 VCM_LOW_OK HS_P_13 0.05565f
C1032 HS_P_4 HS_N_9 0.06578f
C1033 HS_N_8 FS_N_WELL 0.0628f
C1034 VDD HS_N_4 6.43414f
C1035 PULLUP_P_BLEED_2 PULLUP_P_BLEED_3 0.42587f
C1036 LSM_L_P FS_P_CONTROL_S 0.05892f
C1037 TERM_GATE_P TERM_GATE_P_BLEED_6 1.31083f
C1038 TERM_TRIM0 HS_P_8 0.03743f
C1039 TERM_OR_N_B LS_SLOW_B 0.05722f
C1040 PULLDOWN_P_R HS_P_2 0.06892f
C1041 HS_N_12 TERM_GATE_P_BLEED_6 0.03489f
C1042 PULLDOWN_P_R HS_P_1 0.10497f
C1043 LSM_L_N FS_N_CONTROL_S 0
C1044 HS_P_10 HS_N_1 0.03722f
C1045 HS_P_9 HS_N_9 0.03427f
C1046 DIV_P FS_P_OUT 0.04275f
C1047 TERM_OR_N_S PULLUP_N_OUT 0.05414f
C1048 TERM_TRIM1 TERM_GATE_P 0.04081f
C1049 HS_P_10 FS_P_GATE 0.06864f
C1050 HS_N HS_N_11 7.22946f
C1051 VDD PULLUP_P_BLEED_0 0.00193f
C1052 TERM_TRIM1 HS_N_12 0.02846f
C1053 HS_P_12 HS_P_10 0.06569f
C1054 PULLUP_P_BLEED_6 HS_N_0 0.03489f
C1055 PULLUP_P_BLEED_2 TERM_P_R 0.06848f
C1056 FS_N_BLEED_6 TERM_VCM 0.04678f
C1057 TERM_N_R FS_N_BLEED_3 0.08847f
C1058 TERM_P_R PULLDOWN_P 0.13437f
C1059 TERM_GATE_N_BLEED_2 HS_N_10 0
C1060 TERM_GATE_N_BLEED_1 FS_N_GATE 0.05565f
C1061 PULLUP_P_WELL PULLUP_N_OUT 0.77871f
C1062 TERM_GATE_P_BLEED_2 TERM_GATE_P_BLEED_6 0.00257f
C1063 TERM_TRIM2 RX_N 0.01581f
C1064 PULLUP_P_BLEED_2 PULLDOWN_P_R 0.11369f
C1065 PULLUP_P FS_N_GATE 4.76616f
C1066 HS_PBIAS FS_P_BLEED_6 0.09295f
C1067 DIV_LOW_N HS_N_13 0.03894f
C1068 VCM_LOW_OK HS_P_3 0.09755f
C1069 FS_N_BLEED_6 FS_N_BLEED_2 0.01434f
C1070 PULLDOWN_P_R PULLDOWN_P 3.22324f
C1071 HS_PBIAS HS_N_1 1.07255f
C1072 TERM_GATE_P_BLEED_3 TERM_GATE_P_BLEED_6 0.07572f
C1073 PULLUP_N_WELL LSM_L_N 0.00463f
C1074 TERM_LS_N_S PULLDOWN_N_R 0.03788f
C1075 PULLUP_N_GATE LSM_H_N 0.0106f
C1076 HS_PBIAS FS_P_GATE 0.53348f
C1077 TERM_GATE_P_BLEED_1 HS_N_9 0.06246f
C1078 RX_N DIV_LOW_N 0.04393f
C1079 LSNB TERM_P_R 0.05248f
C1080 TERM_OR_P_S HS_P_10 0.00404f
C1081 HS_PBIAS HS_P_12 2.40217f
C1082 HS_N_10 LSM_L_N 0
C1083 FS_P_BLEED_6 HS_N_11 0.03985f
C1084 HS_N DIV_ENABLE 0.04852f
C1085 VDD TERM_TRIM2 10.2624f
C1086 TERM_GATE_P_BLEED_6 HS_N_7 0.03489f
C1087 PULLDOWN_N TERM_N_R 0.1872f
C1088 HS_N_1 HS_N_11 0.06897f
C1089 TERM_GATE_N HS_N_10 0.02545f
C1090 RX_N FS_P_OUT 0.13021f
C1091 TERM_TRIM1 PULLUP_P_GATE 0.03289f
C1092 FS_P_GATE HS_N_11 0.10458f
C1093 FS_LOW_N TERM_P_R 0.08614f
C1094 HS_N_9 HS_N_3 0.04062f
C1095 PULLDOWN_P_R LSNB 0.06315f
C1096 TERM_TRIM0 PULLUP_P_BLEED_6 0.05771f
C1097 HS_P_12 HS_N_11 0.05015f
C1098 VDD DIV_LOW_N 0.4669f
C1099 HS_PBIAS TERM_OR_N_S 0.03743f
C1100 HS_N_4 HS_P 0.30755f
C1101 TERM_TRIM1 PAD_P 0.13157f
C1102 FS_N_WELL LSM_L_N 1.55715f
C1103 FS_P_BLEED_5 LSNB 0.08657f
C1104 HS_N_3 FS_HIGH_P 0.04403f
C1105 TERM_P_R TERM_OR_P_B 0.08908f
C1106 HS_N TERM_N_R 0.5496f
C1107 TERM_GATE_N FS_N_WELL 0.21482f
C1108 TERM_GATE_N_BLEED_1 TERM_LS_N_S 0.10588f
C1109 VDD FS_P_OUT 1.55703f
C1110 LSM_H_N FS_N_BLEED_4 0.0018f
C1111 FS_N_BLEED_6 FS_N_BLEED_5 1.41012f
C1112 FS_P_BLEED_0 HS_N_6 0
C1113 TERM_OR_N_S HS_N_11 0.02404f
C1114 PULLDOWN_P_R FS_LOW_N 0.08926f
C1115 PAD_N HS_N_4 1.23339f
C1116 FS_LOW_P FS_N_OUT 0.1382f
C1117 TERM_OR_P_S HS_PBIAS 0.05252f
C1118 HS_P_0 HS_N_5 0.03733f
C1119 PULLUP_P TERM_LS_N_S 0.04806f
C1120 HS_P_6 HS_N_6 0.0353f
C1121 HS_PBIAS PULLUP_P_WELL 0.48917f
C1122 DIV_N FS_N_OUT 0.15483f
C1123 PULLDOWN_P_R TERM_OR_P_B 0.08328f
C1124 HS_N HS_N_8 4.28657f
C1125 DIV_ENABLE HS_N_1 0.03489f
C1126 TERM_OR_P_S HS_N_11 0.04174f
C1127 DIV_ENABLE FS_P_GATE 0.06282f
C1128 PULLUP_P_WELL HS_N_11 0.17205f
C1129 FS_N_BLEED_3 LSM_L_N 0
C1130 FS_LOW_P HS_N_2 0.04574f
C1131 DIV_ENABLE HS_P_12 0.0056f
C1132 FS_LOW_P FS_P_BLEED_4 0.07139f
C1133 TERM_GATE_N_BLEED_3 HS_N_4 0.04421f
C1134 DIV_N HS_N_2 0.04536f
C1135 DIV_N FS_P_BLEED_4 0.10151f
C1136 RX_N PULLUP_N_OUT 0.03743f
C1137 HS_N_1 TERM_N_R 0.03095f
C1138 TERM_TRIM2 HS_P 0.14141f
C1139 TERM_GATE_P_BLEED_6 PULLDOWN_N_R 0.05221f
C1140 DIV_P HS_PBIAS 0.02968f
C1141 HS_P_0 HS_P_11 0.03053f
C1142 FS_P_GATE TERM_N_R 76.3696f
C1143 PULLUP_P_OUT HS_N_0 0.02689f
C1144 DIV_ENABLE TERM_OR_N_S 0.00795f
C1145 PULLDOWN_N PULLUP_N_BLEED_4 0.00763f
C1146 TERM_OR_N_NS TERM_OR_N_S 0.00306f
C1147 HS_P_5 TERM_ENABLE 0.03489f
C1148 TERM_ENABLE HS_N_0 0.03489f
C1149 HS_P_10 HS_N_13 0.08263f
C1150 PULLUP_P_BLEED_4 FS_N_GATE 0.00193f
C1151 HS_P_8 HS_N_9 0.09748f
C1152 TERM_TRIM1 PULLDOWN_N_R 0.03102f
C1153 HS_P_0 HS_P_13 0.02444f
C1154 TERM_VCM HS_P_7 0.02404f
C1155 VDD PULLUP_N_OUT 3.1909f
C1156 FS_P_BLEED_6 HS_N_8 0.05589f
C1157 DIV_LOW_N HS_P 0.03894f
C1158 PAD_N TERM_TRIM2 1.17745f
C1159 FS_N_OUT FS_N_GATE 10.2658f
C1160 RX_N HS_P_10 0.11913f
C1161 DIV_P HS_N_11 0
C1162 BYPASS_ENABLE DIFF_ENABLE 65.276f
C1163 HS_N_1 HS_N_8 0.03238f
C1164 HS_N TERM_GATE_N_BLEED_2 0.00799f
C1165 TERM_TRIM0 PULLUP_N_BLEED_1 0.05846f
C1166 FS_P_GATE HS_N_8 0.10649f
C1167 DIV_ENABLE PULLUP_P_WELL 0.0279f
C1168 FS_LOW_P VCM_LOW_OK 0.97409f
C1169 TERM_OR_N_S TERM_N_R 0.02404f
C1170 FS_P_OUT HS_P 0.21539f
C1171 HS_P_12 HS_N_8 0.05493f
C1172 DIV_N VCM_LOW_OK 0.00135f
C1173 FS_P_CTLX FS_N_WELL 0
C1174 TERM_GATE_P HS_N_0 0.03931f
C1175 HS_P_5 TERM_GATE_P 0.09149f
C1176 VDD HS_P_10 5.41161f
C1177 FS_LOW_P TERM_OR_N_B 0.08763f
C1178 HS_N_2 FS_N_GATE 0.04032f
C1179 HS_P_5 HS_N_12 0.02482f
C1180 HS_N_12 HS_N_0 0.04999f
C1181 FS_P_BLEED_4 FS_N_GATE 0.05743f
C1182 PAD_N FS_P_OUT 0.77376f
C1183 HS_PBIAS HS_N_13 2.96664f
C1184 DIV_N TERM_OR_N_B 0
C1185 HS_N_8 TERM_OR_N_S 0.02404f
C1186 TERM_GATE_N_BLEED_1 TERM_TRIM1 0.04301f
C1187 TERM_N_R PULLUP_P_WELL 0.29714f
C1188 PAD_N DVDD 61.3963f
C1189 PULLDOWN_P FS_N_CONTROL_S 0.46254f
C1190 HS_N TERM_GATE_N 0.22172f
C1191 RX_P HS_N_4 0.02846f
C1192 HS_P_0 HS_P_3 0.03585f
C1193 RX_N HS_PBIAS 0.74404f
C1194 HS_N_5 HS_N_4 85.8141f
C1195 FS_P_BLEED_2 FS_N_GATE 0.00183f
C1196 TERM_GATE_N_BLEED_3 DIV_LOW_N 0
C1197 HS_P_2 HS_N_10 0.03425f
C1198 LS_SLOW HS_N_4 0.03763f
C1199 TERM_TRIM0 TERM_ENABLE 0.05051f
C1200 TERM_TRIM0 TERM_GATE_N_BLEED_0 0.02274f
C1201 HS_N_11 HS_N_13 0.05491f
C1202 TERM_GATE_N PULLUP_P_CONTROL_S 0.00103f
C1203 HS_N_9 TERM_GATE_N_BLEED_4 0.00148f
C1204 LSM_H_N FS_N_GATE 4.20369f
C1205 DIV_ENABLE DIV_P 12.0354f
C1206 TERM_OR_P_S HS_N_8 0.04751f
C1207 TERM_GATE_N_BLEED_2 HS_N_1 0
C1208 HS_N_8 PULLUP_P_WELL 0.16171f
C1209 HS_P_5 TERM_GATE_P_BLEED_2 0.03151f
C1210 RX_N HS_N_11 0.08253f
C1211 VDD HS_PBIAS 88.33939f
C1212 LSNB FS_N_CONTROL_S 0.52213f
C1213 HS_P_2 FS_N_WELL 0.04908f
C1214 PULLUP_P_BLEED_6 HS_N_9 0.03489f
C1215 HS_P_1 FS_N_WELL 0.09346f
C1216 VCM_LOW_OK FS_N_GATE 0.10148f
C1217 BYPASS_ENABLE FS_P_WELL 0.16151f
C1218 PULLUP_P_BLEED_6 FS_HIGH_P 0.16441f
C1219 DIV_P TERM_N_R 0.03089f
C1220 PULLUP_N_OUT HS_P 0.03743f
C1221 PULLUP_N_WELL PULLDOWN_P 0.13978f
C1222 PULLUP_P_GATE HS_N_0 0.07309f
C1223 TERM_TRIM0 TERM_GATE_P 0.05375f
C1224 TERM_VCM LSM_L_P 21.0282f
C1225 VDD HS_N_11 6.68697f
C1226 HS_P_5 HS_N_7 0.02539f
C1227 TERM_TRIM0 HS_N_12 0.0414f
C1228 LSM_L_P FS_P_WELL 1.82793f
C1229 HS_N_4 LS_SLOW_B 0.05037f
C1230 HS_P_11 HS_N_4 0.06335f
C1231 TERM_OR_N_B FS_N_GATE 0.03408f
C1232 HS_N_10 PULLDOWN_P 0.06611f
C1233 HS_P_5 PAD_P 1.35425f
C1234 HS_N_0 PAD_P 0.10443f
C1235 TERM_GATE_N HS_N_1 0.05002f
C1236 PAD_N PULLUP_N_OUT 0.36561f
C1237 FS_P_BLEED_0 FS_P_WELL 0.034f
C1238 TERM_GATE_N FS_P_GATE 0.04239f
C1239 HS_P_13 HS_N_4 0.02424f
C1240 DIV_ENABLE HS_N_13 0.03489f
C1241 TERM_VCM HS_P_6 0.02404f
C1242 HS_N_12 DIV_LOW_P 0.02888f
C1243 HS_P_6 FS_P_WELL 0.09146f
C1244 TRIM_P_2_R TRIM_P_1_R 0.05735f
C1245 RX_P TERM_TRIM2 0.01945f
C1246 TERM_TRIM2 HS_N_5 0.12138f
C1247 HS_P_10 HS_P 4.07187f
C1248 DIV_ENABLE RX_N 1.08807f
C1249 TERM_TRIM2 LS_SLOW 0.11299f
C1250 RX_N TERM_OR_N_NS 0.05334f
C1251 FS_N_WELL PULLDOWN_P 0.09537f
C1252 LSNB HS_N_10 0.04846f
C1253 RX_P DIV_LOW_N 0.03302f
C1254 HS_N_5 DIV_LOW_N 0.03894f
C1255 PAD_N HS_P_10 0.88842f
C1256 TERM_GATE_N TERM_OR_N_S 0.04458f
C1257 LS_SLOW DIV_LOW_N 0.04641f
C1258 PULLUP_P_BLEED_3 TERM_P_R 0.04401f
C1259 HS_P_7 HS_P_4 0.00106f
C1260 FS_LOW_N PULLUP_N_WELL 0.09128f
C1261 TERM_LS_N_S VCM_LOW_OK 0.00884f
C1262 VDD DIV_ENABLE 0.17433f
C1263 RX_P FS_P_OUT 0.11582f
C1264 HS_N_5 FS_P_OUT 0.04032f
C1265 RX_N TERM_N_R 0.13843f
C1266 LS_SLOW FS_P_OUT 0.90364f
C1267 FS_LOW_N HS_N_10 0.08963f
C1268 TERM_TRIM0 PULLUP_P_GATE 0.04582f
C1269 HS_P_7 HS_P_9 0.08265f
C1270 LSNB FS_N_WELL 0.06243f
C1271 TERM_VCM FS_P_CONTROL_S 0.08313f
C1272 FS_P_BLEED_1 FS_P_OUT 0.04275f
C1273 HS_P_3 HS_N_4 0.08887f
C1274 HS_N_8 HS_N_13 0.05624f
C1275 TERM_LS_N_S TERM_OR_N_B 1.67867f
C1276 PULLDOWN_P_R PULLUP_P_BLEED_3 0.00488f
C1277 HS_PBIAS HS_P 0.17227p
C1278 TERM_GATE_N PULLUP_P_WELL 0.07789f
C1279 HS_N_10 TERM_OR_P_B 0.03308f
C1280 TERM_TRIM0 PAD_P 0.23547f
C1281 TERM_GATE_P_BLEED_6 FS_N_OUT 0.03489f
C1282 TERM_TRIM2 LS_SLOW_B 0.16028f
C1283 TERM_TRIM2 HS_P_11 0.04239f
C1284 TERM_TRIM1 PULLUP_P_BLEED_4 0.01524f
C1285 FS_N_BLEED_3 PULLDOWN_P 0.00384f
C1286 RX_N HS_N_8 0.08135f
C1287 VDD TERM_N_R 2.62779f
C1288 FS_LOW_N FS_N_WELL 0.11634f
C1289 HS_N_7 DIV_LOW_P 0.02846f
C1290 TERM_TRIM1 FS_N_OUT 0.25252f
C1291 TRIM_P_0_R FS_P_OUT 0.01632f
C1292 PAD_N HS_PBIAS 0.00179f
C1293 HS_P_5 PULLDOWN_N_R 0.02411f
C1294 PULLDOWN_N_R HS_N_0 0.02508f
C1295 HS_N_11 HS_P 0.80351f
C1296 PULLUP_N_BLEED_1 FS_HIGH_P 0.094f
C1297 PULLDOWN_P_R TERM_P_R 0.00124f
C1298 DIV_LOW_N LS_SLOW_B 0.05935f
C1299 FS_LOW_P HS_P_0 0.04574f
C1300 FS_N_WELL TERM_OR_P_B 0.15617f
C1301 HS_N_2 TERM_GATE_P_BLEED_6 0.03489f
C1302 HS_N HS_P_2 0.47525f
C1303 FS_P_OUT LS_SLOW_B 0.40618f
C1304 HS_P_11 FS_P_OUT 0.04032f
C1305 VDD HS_N_8 5.12493f
C1306 PAD_N HS_N_11 1.40088f
C1307 HS_N HS_P_1 0.7842f
C1308 TERM_TRIM1 HS_N_2 0.03095f
C1309 DIV_P TERM_GATE_N 0.03089f
C1310 TERM_TRIM1 FS_P_BLEED_4 0.03302f
C1311 FS_P_GATE FS_P_CTLX 0.45602f
C1312 HS_PBIAS TERM_GATE_N_BLEED_3 0.09549f
C1313 PULLUP_P_OUT HS_N_9 0.02404f
C1314 RX_P PULLUP_N_OUT 0.02404f
C1315 TERM_ENABLE HS_N_9 0.03622f
C1316 PULLDOWN_N PULLDOWN_P 23.9475f
C1317 LSM_H_P PULLUP_P_OUT 0.09668f
C1318 HS_N_5 PULLUP_N_OUT 0.05016f
C1319 TERM_ENABLE LSM_H_P 0.04848f
C1320 LS_SLOW PULLUP_N_OUT 0.18558f
C1321 TERM_GATE_N_BLEED_1 HS_N_0 0.03931f
C1322 TERM_TRIM1 FS_P_BLEED_2 0.01442f
C1323 PULLUP_N PULLUP_N_BLEED_1 1.57385f
C1324 TERM_TRIM2 HS_P_3 0.02846f
C1325 FS_P_BLEED_1 PULLUP_N_OUT 0.054f
C1326 TERM_TRIM1 LSM_H_N 0.04182f
C1327 TERM_TRIM2 FS_HIGH_N 0.02404f
C1328 DIV_ENABLE HS_P 0.04774f
C1329 TERM_GATE_N_BLEED_3 HS_N_11 0.03989f
C1330 TERM_TRIM2 PULLUP_N_BLEED_0 0.06219f
C1331 TERM_TRIM0 PULLDOWN_N_R 0.04428f
C1332 VCM_LOW_OK TERM_GATE_P_BLEED_6 1.56309f
C1333 HS_N PULLDOWN_P 0.03656f
C1334 TERM_VCM HS_N_6 0
C1335 RX_P HS_P_10 0.07249f
C1336 LSM_L_P HS_P_9 0.02476f
C1337 HS_P_10 HS_N_5 0.03089f
C1338 FS_P_WELL HS_N_6 0.18212f
C1339 PAD_N DIV_ENABLE 1.63f
C1340 LS_SLOW HS_P_10 0.04428f
C1341 TERM_TRIM1 VCM_LOW_OK 0.04157f
C1342 HS_P_2 HS_N_1 0.03425f
C1343 VDD TERM_GATE_N_BLEED_2 0
C1344 HS_N_9 TERM_GATE_P 0.09149f
C1345 HS_P_4 HS_P_6 0.0298f
C1346 HS_P_1 HS_N_1 0.06806f
C1347 PULLUP_P_OUT TERM_GATE_P_BLEED_4 0.0517f
C1348 HS_P_3 FS_P_OUT 0.04021f
C1349 HS_P_2 FS_P_GATE 0.03722f
C1350 TERM_GATE_N HS_N_13 0.02464f
C1351 PULLUP_N_GATE TERM_TRIM2 0.1096f
C1352 HS_N_12 HS_N_9 0.00792f
C1353 RX_N LSM_L_N 0.07585f
C1354 TERM_N_R HS_P 0.52118f
C1355 HS_P_1 FS_P_GATE 0.06378f
C1356 TERM_ENABLE TERM_GATE_P_BLEED_4 0.0503f
C1357 HS_P_6 HS_P_9 0.04225f
C1358 HS_P_12 HS_P_2 0.04275f
C1359 LS_SLOW_B PULLUP_N_OUT 0.05225f
C1360 HS_N_12 FS_HIGH_P 0.04424f
C1361 PULLUP_P_BLEED_1 HS_N_6 0.04809f
C1362 HS_P_1 HS_P_12 0.06178f
C1363 RX_N TERM_GATE_N 0.16696f
C1364 TERM_TRIM1 TERM_OR_N_B 0.02846f
C1365 HS_N LSNB 0.1866f
C1366 PULLUP_N_BLEED_2 PULLUP_N_BLEED_1 0.96553f
C1367 PAD_N TERM_N_R 3.19026f
C1368 HS_N_8 HS_P 1.16736f
C1369 TERM_GATE_N_BLEED_1 TERM_TRIM0 0.0573f
C1370 VDD LSM_L_N 2.3697f
C1371 RX_P HS_PBIAS 0.36843f
C1372 HS_PBIAS HS_N_5 9.66176f
C1373 TERM_GATE_P_BLEED_2 HS_N_9 0.00148f
C1374 VDD TERM_GATE_N 9.21924f
C1375 FS_LOW_P HS_N_4 0.04574f
C1376 HS_N FS_LOW_N 0.10868f
C1377 LS_SLOW HS_PBIAS 0.82042f
C1378 TERM_GATE_P_BLEED_4 TERM_GATE_P 0.0018f
C1379 HS_P_10 LS_SLOW_B 0.05722f
C1380 HS_P_11 HS_P_10 48.3304f
C1381 HS_N_1 PULLDOWN_P 0.02436f
C1382 DIV_N HS_N_4 0.04536f
C1383 PAD_N HS_N_8 1.19324f
C1384 TERM_TRIM2 FS_N_BLEED_4 0.00333f
C1385 HS_P_10 HS_P_13 0.04481f
C1386 HS_N TERM_OR_P_B 0.08423f
C1387 TERM_OR_P_S HS_P_2 0
C1388 HS_P_8 HS_P_7 31.0392f
C1389 RX_P HS_N_11 0.07411f
C1390 TERM_OR_P_S HS_P_1 0.02037f
C1391 HS_N_5 HS_N_11 0
C1392 FS_LOW_P PULLUP_P_BLEED_0 0.0781f
C1393 PULLUP_P_GATE HS_N_9 0.07578f
C1394 LS_SLOW HS_N_11 0.03515f
C1395 DIV_N PULLUP_P_BLEED_0 0
C1396 PULLUP_P_GATE FS_HIGH_P 0.10576f
C1397 HS_N_9 HS_N_7 0.00982f
C1398 FS_P_BLEED_6 LSNB 0.87093f
C1399 HS_N_9 PAD_P 2.30571f
C1400 HS_P_3 PULLUP_N_OUT 0.05271f
C1401 TERM_ENABLE FS_N_CTLX 0
C1402 HS_N_7 FS_HIGH_P 0.04403f
C1403 FS_HIGH_N PULLUP_N_OUT 0.06357f
C1404 HS_N_1 LSNB 0.04982f
C1405 TERM_OR_N_S PULLDOWN_P 0.03336f
C1406 FS_P_GATE LSNB 0.49607f
C1407 TERM_GATE_N_BLEED_3 HS_N_8 0.05643f
C1408 HS_P_6 HS_N_3 0.02404f
C1409 HS_PBIAS LS_SLOW_B 0.568f
C1410 HS_PBIAS HS_P_11 4.18815f
C1411 TERM_P_R FS_N_CONTROL_S 0.09033f
C1412 HS_P_12 LSNB 0.02805f
C1413 TERM_GATE_P_BLEED_3 TERM_GATE_P_BLEED_4 0.03795f
C1414 PULLUP_N_BLEED_4 HS_P 0.00212f
C1415 PULLUP_P_BLEED_2 PULLUP_P_WELL 0.00979f
C1416 FS_LOW_N HS_N_1 0.08963f
C1417 HS_PBIAS HS_P_13 1.03105f
C1418 DIV_P HS_P_2 0.03388f
C1419 VDD TERM_GATE_P_BLEED_5 0.82754f
C1420 HS_P_3 HS_P_10 0.05151f
C1421 HS_N_0 FS_N_OUT 0.11179f
C1422 HS_N_4 FS_N_GATE 0.05207f
C1423 PULLUP_N_GATE PULLUP_N_OUT 10.3805f
C1424 HS_N_11 LS_SLOW_B 0.04884f
C1425 HS_P_11 HS_N_11 0.10193f
C1426 HS_P_5 FS_N_OUT 0.03577f
C1427 FS_LOW_P TERM_TRIM2 0.01301f
C1428 RX_P DIV_ENABLE 2.21984f
C1429 HS_N_1 TERM_OR_P_B 0.03393f
C1430 DIV_ENABLE HS_N_5 0.0362f
C1431 LSNB TERM_OR_N_S 0.03743f
C1432 RX_P TERM_OR_N_NS 0.03596f
C1433 FS_P_GATE TERM_OR_P_B 0.07417f
C1434 RX_N FS_P_CTLX 0.02332f
C1435 DIV_N TERM_TRIM2 0.07574f
C1436 LS_SLOW TERM_OR_N_NS 0.00299f
C1437 HS_P_12 TERM_OR_P_B 0.08495f
C1438 FS_LOW_P DIV_LOW_N 0.11801f
C1439 TERM_GATE_P_BLEED_0 HS_N_11 0
C1440 PULLUP_N_BLEED_1 PULLUP_N_BLEED_3 0.00131f
C1441 TERM_GATE_N HS_P 0.16894f
C1442 FS_N_BLEED_6 TERM_ENABLE 0.04337f
C1443 DIV_N DIV_LOW_N 5.72167f
C1444 TERM_OR_P_S LSNB 2.03053f
C1445 FS_LOW_N TERM_OR_N_S 4.21685f
C1446 PULLUP_N_WELL TERM_P_R 0.97566f
C1447 HS_N_2 HS_N_0 0
C1448 HS_P_4 HS_N_6 0.03489f
C1449 HS_P_5 HS_N_2 0.02451f
C1450 LSNB PULLUP_P_WELL 0.37429f
C1451 FS_P_BLEED_4 HS_N_0 0.03931f
C1452 RX_P TERM_N_R 0.1019f
C1453 HS_N_5 TERM_N_R 0.07026f
C1454 TERM_GATE_N_BLEED_3 TERM_GATE_N_BLEED_2 0.05305f
C1455 VDD FS_P_CTLX 2.64336f
C1456 FS_LOW_P FS_P_OUT 0.04158f
C1457 LS_SLOW TERM_N_R 0.60891f
C1458 HS_N_10 TERM_P_R 0.13175f
C1459 PAD_N TERM_GATE_N 1.10596f
C1460 HS_P_9 HS_N_6 0.03425f
C1461 DIV_N FS_P_OUT 0.08248f
C1462 PULLUP_P_BLEED_3 FS_N_WELL 0.09013f
C1463 HS_PBIAS HS_P_3 8.69477f
C1464 FS_P_BLEED_1 TERM_N_R 0.07785f
C1465 HS_PBIAS FS_HIGH_N 0.12258f
C1466 HS_N_9 PULLDOWN_N_R 0.06159f
C1467 HS_P_2 HS_N_13 0.03586f
C1468 LSM_H_P PULLDOWN_N_R 0.00267f
C1469 HS_P_1 HS_N_13 0.01821f
C1470 HS_P_0 TERM_GATE_P_BLEED_6 0.03489f
C1471 DIV_ENABLE HS_P_11 0.00932f
C1472 PULLDOWN_N_R FS_HIGH_P 0.06207f
C1473 RX_P HS_N_8 0.0416f
C1474 HS_N_5 HS_N_8 0.04347f
C1475 TERM_TRIM0 PULLUP_P_BLEED_4 0.03856f
C1476 TERM_OR_P_NS TERM_OR_P_B 0.45686f
C1477 TERM_VCM FS_P_WELL 1.26777f
C1478 TERM_OR_P_S TERM_OR_P_B 1.35042f
C1479 RX_N HS_P_2 0.0348f
C1480 PULLDOWN_P_R HS_N_10 0.02988f
C1481 TERM_P_R FS_N_WELL 0.19247f
C1482 RX_N HS_P_1 0.1244f
C1483 TERM_LS_N_S HS_N_4 0.00196f
C1484 HS_P_8 HS_P_6 0.00206f
C1485 TERM_TRIM0 FS_N_OUT 3.45337f
C1486 DIV_ENABLE HS_P_13 0.0039f
C1487 FS_P_BLEED_5 HS_N_10 0
C1488 TERM_TRIM2 FS_N_GATE 0.19833f
C1489 DIV_ENABLE TERM_GATE_P_BLEED_0 0
C1490 PULLUP_N_GATE HS_PBIAS 0.08876f
C1491 DIV_P LSNB 0.07276f
C1492 HS_P_5 VCM_LOW_OK 0.05344f
C1493 VCM_LOW_OK HS_N_0 0.02404f
C1494 TERM_N_R LS_SLOW_B 0.449f
C1495 HS_P_11 TERM_N_R 0.02846f
C1496 FS_N_OUT DIV_LOW_P 0.1217f
C1497 VDD HS_P_2 5.98282f
C1498 DIV_LOW_N FS_N_GATE 0.04488f
C1499 VDD HS_P_1 5.7423f
C1500 PULLUP_N_BLEED_6 TERM_VCM 0.00196f
C1501 TERM_GATE_P_BLEED_1 HS_N_6 0.04809f
C1502 TERM_GATE_N_BLEED_1 HS_N_9 0.03931f
C1503 TERM_TRIM2 TERM_GATE_N_BLEED_6 0.00333f
C1504 HS_P_13 TERM_N_R 0.05499f
C1505 TERM_TRIM0 HS_N_2 0.04428f
C1506 TERM_OR_N_B HS_N_0 0.05832f
C1507 TERM_TRIM0 FS_P_BLEED_4 0.04208f
C1508 HS_N_13 PULLDOWN_P 0.02404f
C1509 TERM_GATE_N_BLEED_1 FS_HIGH_P 0.15762f
C1510 PULLUP_N PULLDOWN_N_R 0.08499f
C1511 PULLUP_P HS_N_9 0
C1512 FS_P_OUT FS_N_GATE 2.10569f
C1513 FS_LOW_P PULLUP_N_OUT 0.04792f
C1514 HS_P_11 HS_N_8 0.06578f
C1515 PULLUP_N_BLEED_6 PULLUP_N_BLEED_5 0.03602f
C1516 HS_N_2 DIV_LOW_P 0.02846f
C1517 TERM_GATE_N_BLEED_6 DIV_LOW_N 0.00832f
C1518 TERM_P_R FS_N_BLEED_3 0.06545f
C1519 BYPASS_ENABLE PULLUP_P_BLEED_6 0.00766f
C1520 DIV_N PULLUP_N_OUT 0.05408f
C1521 TERM_TRIM0 FS_P_BLEED_2 0.02498f
C1522 DIV_ENABLE HS_P_3 0.00256f
C1523 HS_P_13 HS_N_8 0.0311f
C1524 HS_N_3 HS_N_6 0.08284f
C1525 TERM_TRIM0 LSM_H_N 0.05476f
C1526 DIV_ENABLE FS_HIGH_N 11.221f
C1527 LSNB HS_N_13 0.09455f
C1528 TERM_TRIM2 TERM_LS_P_S 0.07232f
C1529 VDD PULLDOWN_P 0.82551f
C1530 FS_N_OUT FS_N_BLEED_1 0.85952f
C1531 FS_LOW_P HS_P_10 0.04574f
C1532 TERM_VCM FS_N_BLEED_5 0.84584f
C1533 RX_N LSNB 0.04778f
C1534 TERM_TRIM0 VCM_LOW_OK 0.05451f
C1535 RX_P LSM_L_N 0.04849f
C1536 HS_P_3 TERM_N_R 0.03089f
C1537 HS_N_5 LSM_L_N 0
C1538 FS_HIGH_N TERM_N_R 0.15091f
C1539 PULLUP_N_GATE DIV_ENABLE 0
C1540 FS_LOW_N HS_N_13 0.13016f
C1541 LS_SLOW LSM_L_N 5.23233f
C1542 PULLUP_N_CONTROL_S PULLUP_N_BLEED_1 0.00204f
C1543 RX_P TERM_GATE_N 0.14113f
C1544 TERM_GATE_N HS_N_5 0.05544f
C1545 PULLDOWN_N TERM_P_R 0.29513f
C1546 LS_SLOW TERM_GATE_N 0.13789f
C1547 PULLDOWN_N_R FS_N_CTLX 0.04021f
C1548 TERM_TRIM0 TERM_OR_N_B 0.0414f
C1549 HS_N_13 TERM_OR_P_B 0.0318f
C1550 RX_N FS_LOW_N 0.03494f
C1551 TERM_LS_P_S FS_P_OUT 0
C1552 VDD LSNB 3.18253f
C1553 TERM_GATE_N FS_P_BLEED_1 0.03449f
C1554 TERM_GATE_P_BLEED_6 HS_N_4 0.03489f
C1555 HS_P_3 HS_N_8 0.03089f
C1556 HS_P_7 TERM_ENABLE 0.03489f
C1557 FS_N_GATE PULLUP_N_OUT 0.10163f
C1558 RX_N TERM_OR_P_B 0.10926f
C1559 HS_P_2 HS_P 3.52198f
C1560 TERM_TRIM1 HS_N_4 0.04506f
C1561 PULLUP_N_GATE TERM_N_R 0.33395f
C1562 HS_P_1 HS_P 5.81948f
C1563 FS_LOW_P HS_PBIAS 0.38773f
C1564 HS_N TERM_P_R 0.44001f
C1565 VDD FS_LOW_N 1.16088f
C1566 DIV_N HS_PBIAS 0.12658f
C1567 PAD_N HS_P_2 0.4153f
C1568 PAD_N HS_P_1 1.59819f
C1569 LS_SLOW_B LSM_L_N 3.47448f
C1570 FS_N_OUT FS_N_BLEED_0 0.07979f
C1571 VDD TERM_OR_P_B 11.177f
C1572 FS_LOW_P HS_N_11 0.04601f
C1573 TERM_VCM HS_P_4 0.02417f
C1574 TERM_TRIM1 TRIM_P_2_R 0
C1575 HS_P_10 FS_N_GATE 0.07865f
C1576 HS_P_4 FS_P_WELL 0.04122f
C1577 TERM_GATE_N LS_SLOW_B 0.13174f
C1578 HS_P_11 TERM_GATE_N 0.02846f
C1579 DIV_N HS_N_11 0.04536f
C1580 HS_N PULLDOWN_P_R 0.08577f
C1581 BYPASS_ENABLE PULLUP_N_BLEED_1 0.00766f
C1582 HS_P_7 TERM_GATE_P 0.04872f
C1583 TERM_VCM HS_P_9 0.08595f
C1584 PULLUP_P_BLEED_2 HS_P 0.00212f
C1585 PULLUP_P FS_N_CTLX 0.05432f
C1586 FS_N_BLEED_6 PULLDOWN_N_R 0.04859f
C1587 HS_P_9 FS_P_WELL 0.04122f
C1588 HS_N FS_P_BLEED_5 0.00735f
C1589 HS_P PULLDOWN_P 0.02404f
C1590 TERM_TRIM2 TERM_GATE_P_BLEED_6 0.04124f
C1591 TERM_LS_N_S PULLUP_N_OUT 0.18572f
C1592 FS_N_OUT FS_HIGH_P 0.1423f
C1593 HS_N_1 TERM_P_R 0.04412f
C1594 TERM_TRIM2 TERM_TRIM1 0.22046p
C1595 FS_P_GATE TERM_P_R 0.14122f
C1596 HS_PBIAS FS_N_GATE 0.72815f
C1597 FS_N_WELL FS_N_CONTROL_S 0.07444f
C1598 HS_P_7 TERM_GATE_P_BLEED_2 0.03089f
C1599 HS_P_5 HS_P_0 0.02404f
C1600 LSNB HS_P 0.10316f
C1601 FS_LOW_P DIV_ENABLE 0.08085f
C1602 RX_P FS_P_CTLX 0.01816f
C1603 HS_N_2 HS_N_9 0.04059f
C1604 LS_SLOW FS_P_CTLX 0.03817f
C1605 DIV_N DIV_ENABLE 30.2338f
C1606 FS_HIGH_N LSM_L_N 0.0468f
C1607 TERM_GATE_N_BLEED_4 HS_N_6 0
C1608 FS_P_BLEED_4 HS_N_9 0.03931f
C1609 TERM_TRIM1 DIV_LOW_N 0.03302f
C1610 FS_P_BLEED_6 FS_P_BLEED_5 0.10979f
C1611 TERM_GATE_P_BLEED_1 FS_P_WELL 0.05773f
C1612 PULLDOWN_P_R HS_N_1 0.03041f
C1613 TERM_GATE_N HS_P_3 0.03089f
C1614 FS_P_BLEED_4 LSM_H_P 0.5719f
C1615 TERM_GATE_P_BLEED_6 FS_P_OUT 0.05327f
C1616 HS_N_2 FS_HIGH_P 0.04403f
C1617 HS_N_11 FS_N_GATE 0.0924f
C1618 PULLUP_N_GATE PULLUP_N_BLEED_4 0
C1619 TERM_GATE_P_BLEED_5 LS_SLOW_B 0.00265f
C1620 FS_P_BLEED_4 FS_HIGH_P 0.16851f
C1621 PULLDOWN_P_R FS_P_GATE 15.5677f
C1622 FS_N_BLEED_6 PULLUP_P 0.05953f
C1623 PAD_N LSNB 0.00261f
C1624 FS_P_BLEED_5 HS_N_1 0
C1625 FS_LOW_N HS_P 0.08963f
C1626 TERM_OR_N_S TERM_P_R 0.03309f
C1627 TERM_TRIM1 FS_P_OUT 0.06038f
C1628 PULLDOWN_P_R HS_P_12 0.03738f
C1629 HS_P_7 HS_N_7 0
C1630 FS_LOW_P TERM_N_R 0.10898f
C1631 PULLUP_P_BLEED_3 PULLUP_P_WELL 0
C1632 PULLUP_P_BLEED_6 HS_N_6 0.03489f
C1633 FS_P_BLEED_2 LSM_H_P 0.0018f
C1634 HS_P_7 PAD_P 1.23297f
C1635 HS_P TERM_OR_P_B 0.03147f
C1636 TERM_ENABLE HS_P_6 0.03489f
C1637 DIV_N TERM_N_R 0.10571f
C1638 BYPASS_ENABLE TERM_GATE_P 0.01055f
C1639 PULLUP_N_GATE LSM_L_N 0.12528f
C1640 HS_N_3 FS_P_WELL 0.23277f
C1641 PULLUP_N_WELL FS_N_WELL 0.01684f
C1642 PULLUP_P_WELL TERM_P_R 0.3769f
C1643 TERM_GATE_N_BLEED_3 LSNB 0.0079f
C1644 FS_LOW_P HS_N_8 0.04574f
C1645 LSM_L_P TERM_GATE_P 3.8124f
C1646 HS_N_10 FS_N_WELL 0.05647f
C1647 RX_P HS_P_2 0.02846f
C1648 FS_P_CTLX LS_SLOW_B 2.23952f
C1649 HS_N_5 HS_P_2 0.03089f
C1650 VCM_LOW_OK HS_N_9 0.02579f
C1651 PULLUP_P_BLEED_1 HS_N_3 0.04313f
C1652 RX_P HS_P_1 0.08271f
C1653 TERM_LS_P_S HS_PBIAS 0.62796f
C1654 HS_P_1 HS_N_5 0.03097f
C1655 HS_PBIAS TERM_LS_N_S 0.37368f
C1656 LS_SLOW HS_P_2 0.03763f
C1657 VCM_LOW_OK LSM_H_P 0.04616f
C1658 DIV_N HS_N_8 0.04536f
C1659 LS_SLOW HS_P_1 0.00299f
C1660 VCM_LOW_OK FS_HIGH_P 0.02829f
C1661 DIV_ENABLE FS_N_GATE 0.0879f
C1662 TERM_OR_N_NS FS_N_GATE 0.03693f
C1663 PULLDOWN_P_R PULLUP_P_WELL 0.34662f
C1664 HS_P_6 TERM_GATE_P 0.03931f
C1665 HS_N_9 TERM_OR_N_B 0.0599f
C1666 FS_P_CONTROL_S PULLUP_P_OUT 0.04356f
C1667 HS_P_6 HS_N_12 0.02482f
C1668 TERM_ENABLE FS_P_CONTROL_S 0.03089f
C1669 FS_P_BLEED_5 PULLUP_P_WELL 0
C1670 HS_P_0 DIV_LOW_P 0.0881f
C1671 TERM_OR_N_B FS_HIGH_P 0.00481f
C1672 TERM_GATE_P_BLEED_6 PULLUP_N_OUT 0.11263f
C1673 FS_N_BLEED_4 LSM_L_N 0.33395f
C1674 PULLUP_P_BLEED_5 VDD 0.82675f
C1675 PULLUP_P_BLEED_2 HS_N_5 0
C1676 DIV_P TERM_P_R 0.04275f
C1677 TERM_TRIM1 PULLUP_N_OUT 0.02404f
C1678 TERM_N_R FS_N_GATE 0.17128f
C1679 BYPASS_ENABLE PULLUP_P_GATE 0
C1680 HS_N_5 PULLDOWN_P 0.06583f
C1681 HS_P_2 LS_SLOW_B 0.05037f
C1682 HS_P_11 HS_P_2 0.0392f
C1683 HS_P_4 HS_P_9 0.03887f
C1684 LS_SLOW PULLDOWN_P 0.04509f
C1685 HS_P_1 HS_P_11 0.06178f
C1686 HS_P_5 HS_N_4 0.03052f
C1687 HS_N_4 HS_N_0 0
C1688 HS_P_7 PULLDOWN_N_R 0.06544f
C1689 FS_LOW_P TERM_GATE_N_BLEED_2 0.05872f
C1690 TERM_GATE_P_BLEED_2 HS_P_6 0.03089f
C1691 BYPASS_ENABLE PAD_P 2.96529f
C1692 HS_P_10 TERM_GATE_P_BLEED_6 0.03489f
C1693 HS_P_2 HS_P_13 35.6147f
C1694 TERM_VCM HS_P_8 0.02404f
C1695 DIV_N TERM_GATE_N_BLEED_2 0.03911f
C1696 HS_P_1 HS_P_13 0.08042f
C1697 HS_N_8 FS_N_GATE 0.0359f
C1698 HS_N FS_N_CONTROL_S 0.06123f
C1699 FS_N_WELL FS_N_BLEED_3 0.09065f
C1700 TERM_TRIM1 HS_P_10 0.02846f
C1701 PULLUP_P_BLEED_0 HS_N_0 0
C1702 RX_P LSNB 0.04145f
C1703 FS_P_BLEED_0 HS_N_7 0
C1704 HS_N_5 LSNB 0.04524f
C1705 PULLUP_N_CONTROL_S PULLDOWN_N_R 0.03786f
C1706 LS_SLOW LSNB 0.05252f
C1707 RX_N PULLUP_P_BLEED_3 0.0213f
C1708 HS_P_6 HS_N_7 0.00816f
C1709 FS_N_BLEED_6 FS_N_OUT 0.05805f
C1710 HS_P_6 PAD_P 1.77494f
C1711 FS_LOW_P TERM_GATE_N 0.03226f
C1712 LS_SLOW_B PULLDOWN_P 0.03937f
C1713 RX_P FS_LOW_N 0.02404f
C1714 FS_LOW_N HS_N_5 0.08963f
C1715 HS_P_4 TERM_GATE_P_BLEED_1 0
C1716 DIV_N TERM_GATE_N 0.09965f
C1717 RX_N TERM_P_R 0.26331f
C1718 TERM_LS_N_S TERM_N_R 0.04195f
C1719 LS_SLOW FS_LOW_N 0.03743f
C1720 HS_PBIAS TERM_GATE_P_BLEED_6 0.04247f
C1721 HS_N PULLUP_N_WELL 0.432f
C1722 RX_P TERM_OR_P_B 0.0676f
C1723 HS_N_5 TERM_OR_P_B 0.03089f
C1724 HS_P_3 HS_P_2 34.33f
C1725 PULLUP_P_OUT HS_N_6 0.02404f
C1726 HS_P_1 HS_P_3 0.07442f
C1727 PULLDOWN_P_R HS_N_13 0.02906f
C1728 LS_SLOW TERM_OR_P_B 0.04795f
C1729 TERM_TRIM1 HS_PBIAS 0.81983f
C1730 TERM_ENABLE HS_N_6 0.03548f
C1731 TERM_TRIM0 HS_N_4 0.03698f
C1732 HS_N HS_N_10 5.19817f
C1733 HS_P_4 HS_N_3 0.03489f
C1734 TERM_GATE_P_BLEED_6 HS_N_11 0.03489f
C1735 TERM_TRIM2 HS_P_5 0.04239f
C1736 LSNB LS_SLOW_B 0.07424f
C1737 HS_P_11 LSNB 0.04828f
C1738 VDD TERM_P_R 2.33137f
C1739 TERM_LS_N_S HS_N_8 0.00704f
C1740 PULLUP_P PULLUP_N_CONTROL_S 0
C1741 TERM_TRIM1 HS_N_11 0.09971f
C1742 HS_P_9 HS_N_3 0.03425f
C1743 HS_N_4 DIV_LOW_P 0.02846f
C1744 HS_P_13 LSNB 0.02068f
C1745 TERM_GATE_N_BLEED_5 TERM_GATE_N_BLEED_4 0.06051f
C1746 DIV_LOW_N HS_N_0 0.03929f
C1747 HS_N FS_N_WELL 0.43688f
C1748 FS_N_BLEED_6 LSM_H_N 1.08334f
C1749 TERM_VCM PULLUP_P_BLEED_6 0.04848f
C1750 TERM_GATE_P_BLEED_0 LSNB 0.08657f
C1751 FS_LOW_N LS_SLOW_B 0.05037f
C1752 VDD PULLDOWN_P_R 1.05422f
C1753 TERM_GATE_P HS_N_6 0.03931f
C1754 FS_N_GATE LSM_L_N 0.16025f
C1755 PULLUP_P_CONTROL_S FS_N_WELL 0.03407f
C1756 HS_P_5 FS_P_OUT 0.04032f
C1757 VDD FS_P_BLEED_5 0.00257f
C1758 HS_N_12 HS_N_6 0.0742f
C1759 LS_SLOW_B TERM_OR_P_B 0.05037f
C1760 HS_P_11 TERM_OR_P_B 0.08006f
C1761 FS_HIGH_N PULLDOWN_P 0.056f
C1762 TERM_GATE_N FS_N_GATE 0.1068p
C1763 FS_P_BLEED_0 PULLDOWN_N_R 0.06686f
C1764 PULLUP_P_BLEED_6 PULLUP_P_BLEED_1 0.00257f
C1765 DIFF_ENABLE PULLUP_N_BLEED_1 0.00113f
C1766 FS_P_BLEED_6 HS_N_10 0.04001f
C1767 HS_P_13 TERM_OR_P_B 0.05824f
C1768 HS_P_6 PULLDOWN_N_R 0.02414f
C1769 HS_P_0 HS_N_9 0.03775f
C1770 DIV_ENABLE TERM_GATE_P_BLEED_6 0.0884f
C1771 HS_N_1 HS_N_10 89.709f
C1772 BYPASS_ENABLE TERM_GATE_N_BLEED_1 0.00766f
C1773 FS_P_GATE HS_N_10 0.1023f
C1774 TERM_GATE_N TERM_GATE_N_BLEED_6 0.00162f
C1775 TERM_GATE_P_BLEED_1 HS_N_3 0.04313f
C1776 TERM_TRIM2 TERM_TRIM0 0.09098f
C1777 DIV_ENABLE TERM_TRIM1 0.15985f
C1778 HS_P_12 HS_N_10 0.05724f
C1779 PULLUP_N_GATE PULLDOWN_P 0.10346f
C1780 FS_HIGH_N LSNB 0.0736f
C1781 TERM_GATE_P_BLEED_2 HS_N_6 0
C1782 HS_N_1 FS_N_WELL 0.0628f
C1783 TERM_TRIM0 DIV_LOW_N 0.0633f
C1784 FS_P_GATE FS_N_WELL 0.06145f
C1785 TERM_GATE_P_BLEED_6 TERM_N_R 0.03542f
C1786 HS_P_8 HS_P_4 0
C1787 TERM_OR_N_S HS_N_10 0.02404f
C1788 TERM_ENABLE DIFF_ENABLE 0.01268f
C1789 FS_HIGH_N FS_LOW_N 0.08901f
C1790 FS_P_CONTROL_S PULLDOWN_N_R 0.00267f
C1791 PULLUP_P_GATE HS_N_6 0.07367f
C1792 TERM_P_R HS_P 0.35922f
C1793 TERM_TRIM1 TERM_N_R 0.07099f
C1794 HS_P_8 HS_P_9 29.673f
C1795 TERM_TRIM0 FS_P_OUT 0.06122f
C1796 HS_N_7 HS_N_6 84.313f
C1797 HS_P_3 TERM_OR_P_B 0.05673f
C1798 TERM_LS_P_S TERM_GATE_N 0
C1799 TERM_LS_N_S TERM_GATE_N 1.16881f
C1800 HS_N_6 PAD_P 0.06903f
C1801 TERM_GATE_P_BLEED_6 HS_N_8 0.03489f
C1802 TERM_OR_P_S HS_N_10 0.04189f
C1803 PAD_N TERM_P_R 0.7815f
C1804 TERM_OR_N_S FS_N_WELL 0.53849f
C1805 HS_N_10 PULLUP_P_WELL 0.18087f
C1806 PULLDOWN_P_R HS_P 0.03102f
C1807 TERM_VCM PULLUP_N_BLEED_1 0.04848f
C1808 PULLUP_N_GATE FS_LOW_N 0.10954f
C1809 FS_LOW_P HS_P_2 0.04566f
C1810 FS_LOW_P HS_P_1 0.04574f
C1811 DIV_N HS_P_2 0
C1812 HS_P_5 HS_P_10 0.03789f
C1813 PAD_N PULLDOWN_P_R 0.07943f
C1814 PULLUP_P_WELL FS_N_WELL 0.10824f
C1815 HS_N_13 FS_N_CONTROL_S 0
C1816 DIV_P HS_N_10 0
C1817 TERM_VCM PULLUP_P_OUT 0.08226f
C1818 HS_N_9 HS_N_4 0.04068f
C1819 TERM_VCM TERM_GATE_N_BLEED_0 0.84134f
C1820 PULLUP_P_OUT FS_P_WELL 0.12609f
C1821 TERM_VCM TERM_ENABLE 0.06862f
C1822 RX_N FS_N_CONTROL_S 0.05956f
C1823 TERM_ENABLE FS_P_WELL 0.11854f
C1824 TERM_TRIM0 PULLUP_N_OUT 0.03743f
C1825 HS_N_4 FS_HIGH_P 0.04403f
C1826 TERM_ENABLE TERM_GATE_N_BLEED_5 0.00311f
C1827 DIV_N PULLDOWN_P 0.05579f
C1828 HS_PBIAS HS_N_0 0.85235f
C1829 HS_P_5 HS_PBIAS 2.13715f
C1830 TERM_ENABLE PULLUP_N_BLEED_5 0.00291f
C1831 PULLUP_P_BLEED_5 LS_SLOW_B 0.00265f
C1832 DIV_P FS_N_WELL 0.05366f
C1833 PULLUP_P_BLEED_1 PULLUP_P_OUT 0
C1834 PULLDOWN_N_R HS_N_6 0.02404f
C1835 PULLUP_P_BLEED_0 FS_HIGH_P 0.03577f
C1836 VDD FS_N_CONTROL_S 0.18308f
C1837 HS_P_2 FS_N_GATE 0.04275f
C1838 HS_N FS_P_BLEED_6 0.05372f
C1839 HS_P_7 VCM_LOW_OK 0.10209f
C1840 HS_P_1 FS_N_GATE 0.07622f
C1841 BYPASS_ENABLE FS_N_OUT 0.22643f
C1842 TERM_TRIM0 HS_P_10 0.0414f
C1843 HS_N_0 HS_N_11 0.00264f
C1844 HS_P_5 HS_N_11 0.02508f
C1845 HS_N HS_N_1 5.73614f
C1846 PULLUP_N_BLEED_6 TERM_ENABLE 0.04817f
C1847 TERM_VCM TERM_GATE_P 6.92167f
C1848 FS_LOW_P LSNB 0.12796f
C1849 HS_N FS_P_GATE 0.37962f
C1850 TERM_GATE_N TERM_GATE_P_BLEED_6 0.04387f
C1851 TERM_GATE_P FS_P_WELL 0.11767f
C1852 RX_P PULLUP_P_BLEED_3 0.00418f
C1853 TERM_TRIM1 LSM_L_N 0.04182f
C1854 TERM_VCM HS_N_12 0.03637f
C1855 LS_SLOW PULLUP_P_BLEED_3 0
C1856 HS_N_10 HS_N_13 0.05677f
C1857 HS_N_12 FS_P_WELL 0.19038f
C1858 DIV_N LSNB 0.05919f
C1859 HS_N HS_P_12 0.41804f
C1860 RX_N PULLUP_N_WELL 0.30408f
C1861 HS_P_10 DIV_LOW_P 0.08231f
C1862 TERM_TRIM1 TERM_GATE_N 0.12458f
C1863 RX_N HS_N_10 0.08407f
C1864 RX_P TERM_P_R 0.25234f
C1865 HS_N_5 TERM_P_R 0.08415f
C1866 FS_LOW_P FS_LOW_N 0.11675p
C1867 TERM_GATE_N_BLEED_1 HS_N_6 0.03931f
C1868 BYPASS_ENABLE FS_P_BLEED_4 0.00766f
C1869 PULLUP_P_BLEED_1 HS_N_12 0.03976f
C1870 LS_SLOW TERM_P_R 2.25971f
C1871 TERM_TRIM2 HS_N_9 0.04239f
C1872 HS_P_6 FS_N_OUT 0.04459f
C1873 DIV_N FS_LOW_N 0.0462f
C1874 FS_N_WELL HS_N_13 0.00162f
C1875 HS_N TERM_OR_N_S 0.03336f
C1876 TERM_TRIM2 LSM_H_P 0.04182f
C1877 VDD PULLUP_N_WELL 9.92233f
C1878 FS_P_BLEED_1 TERM_P_R 0.04401f
C1879 FS_LOW_P TERM_OR_P_B 3.50435f
C1880 FS_N_GATE PULLDOWN_P 0.07384f
C1881 TERM_TRIM0 HS_PBIAS 0.51017f
C1882 LSM_L_P FS_P_BLEED_4 0.0364f
C1883 HS_N_9 DIV_LOW_N 0.03894f
C1884 RX_N FS_N_WELL 12.8258f
C1885 VDD HS_N_10 6.607f
C1886 PULLDOWN_P_R HS_N_5 0.02903f
C1887 DIV_ENABLE HS_P_5 0.00128f
C1888 FS_P_BLEED_6 HS_N_1 0.04023f
C1889 DIV_ENABLE HS_N_0 0.03489f
C1890 PULLUP_P_BLEED_6 HS_N_3 0.03489f
C1891 LS_SLOW PULLDOWN_P_R 0.00417f
C1892 HS_N TERM_OR_P_S 0.05127f
C1893 FS_P_BLEED_4 FS_P_BLEED_0 0.00257f
C1894 DIV_LOW_N FS_HIGH_P 0.01124f
C1895 FS_P_BLEED_6 FS_P_GATE 0.034f
C1896 HS_P_6 HS_N_2 0.02451f
C1897 HS_PBIAS DIV_LOW_P 0.14446f
C1898 HS_N PULLUP_P_WELL 0.29058f
C1899 PULLDOWN_P_R FS_P_BLEED_1 0.00488f
C1900 HS_N_9 FS_P_OUT 0.04032f
C1901 FS_P_GATE HS_N_1 0.10845f
C1902 LSM_L_P FS_P_BLEED_2 0.00148f
C1903 PULLUP_P_GATE TERM_VCM 0.0408f
C1904 TERM_TRIM0 HS_N_11 0.07441f
C1905 PULLUP_P_GATE FS_P_WELL 0.00204f
C1906 LSM_H_P FS_P_OUT 0.77187f
C1907 HS_P_12 HS_N_1 0.05736f
C1908 TERM_GATE_P_BLEED_5 TERM_GATE_P_BLEED_6 1.41012f
C1909 TERM_VCM HS_N_7 0
C1910 PULLUP_P_CONTROL_S PULLUP_P_WELL 0.00114f
C1911 VDD FS_N_WELL 70.4297f
C1912 LSNB FS_N_GATE 0.15267f
C1913 HS_N_7 FS_P_WELL 0.14431f
C1914 HS_P_12 FS_P_GATE 0.00305f
C1915 TERM_TRIM2 TERM_GATE_P_BLEED_4 0.00333f
C1916 LS_SLOW_B TERM_P_R 2.9273f
C1917 HS_P_11 TERM_P_R 0.04032f
C1918 TERM_VCM PAD_P 0.18519f
C1919 FS_P_WELL PAD_P 2.16992f
C1920 HS_P FS_N_CONTROL_S 0.04185f
C1921 HS_N_11 DIV_LOW_P 0.029f
C1922 HS_P_5 TERM_N_R 0.02846f
C1923 TERM_TRIM1 TERM_GATE_P_BLEED_5 0.1248f
C1924 DIFF_ENABLE PULLDOWN_N_R 0
C1925 PULLUP_P_GATE PULLUP_P_BLEED_1 0
C1926 HS_P_13 TERM_P_R 0.08979f
C1927 HS_N_1 TERM_OR_N_S 0.02404f
C1928 PULLUP_P_BLEED_1 HS_N_7 0.05151f
C1929 FS_LOW_N FS_N_GATE 0.11862f
C1930 RX_N FS_N_BLEED_3 0.0213f
C1931 PULLDOWN_P_R HS_P_11 0.0383f
C1932 VCM_LOW_OK FS_P_BLEED_0 0.85662f
C1933 TERM_LS_N_S PULLDOWN_P 0.03506f
C1934 HS_P_5 HS_N_8 0.05493f
C1935 HS_N DIV_P 0.08244f
C1936 FS_N_GATE TERM_OR_P_B 0.1335f
C1937 PULLDOWN_P_R HS_P_13 0.02633f
C1938 HS_P_4 TERM_ENABLE 0.03489f
C1939 VCM_LOW_OK HS_P_6 0.0531f
C1940 FS_P_BLEED_6 PULLUP_P_WELL 0.00106f
C1941 HS_PBIAS FS_N_BLEED_1 0.09581f
C1942 TERM_OR_P_S HS_N_1 0.04195f
C1943 TERM_TRIM2 TRIM_N_2_R 0.59166f
C1944 DIV_ENABLE TERM_TRIM0 0.07779f
C1945 PULLUP_P_OUT HS_P_9 0.04113f
C1946 FS_P_BLEED_3 FS_P_GATE 0
C1947 TERM_TRIM1 FS_P_CTLX 0.03947f
C1948 HS_N_1 PULLUP_P_WELL 0.18986f
C1949 TERM_ENABLE HS_P_9 0.07426f
C1950 PULLUP_N_WELL HS_P 0.16057f
C1951 TERM_OR_P_S HS_P_12 0
C1952 HS_N_9 PULLUP_N_OUT 0.0044f
C1953 DIV_ENABLE DIV_LOW_P 2.35508f
C1954 PULLUP_P DIFF_ENABLE 0.0515f
C1955 HS_N_10 HS_P 0.24463f
C1956 HS_P_3 TERM_P_R 0.03089f
C1957 LSM_H_P PULLUP_N_OUT 0.04585f
C1958 FS_HIGH_N TERM_P_R 0.06496f
C1959 PULLUP_N_OUT FS_HIGH_P 0.00145f
C1960 RX_N PULLDOWN_N 0.04828f
C1961 TERM_TRIM0 TERM_N_R 0.08918f
C1962 HS_P_4 TERM_GATE_P 0.08707f
C1963 VCM_LOW_OK FS_P_CONTROL_S 0.05156f
C1964 HS_P_4 HS_N_12 0.03489f
C1965 PAD_N HS_N_10 1.30184f
C1966 HS_N HS_N_13 1.99757f
C1967 TERM_VCM PULLDOWN_N_R 0.08363f
C1968 HS_P_2 TERM_GATE_P_BLEED_6 0.03489f
C1969 HS_P_9 TERM_GATE_P 0.05022f
C1970 PULLDOWN_N_R FS_P_WELL 0.1715f
C1971 FS_N_WELL HS_P 0.43143f
C1972 PULLDOWN_P_R HS_P_3 0.0686f
C1973 HS_P_1 TERM_GATE_P_BLEED_6 0.03489f
C1974 DIV_P HS_N_1 0
C1975 TERM_GATE_N_BLEED_2 HS_N_0 0
C1976 HS_N_12 HS_P_9 0.03425f
C1977 HS_P_10 HS_N_9 0.03109f
C1978 HS_P_0 HS_P_7 0.02404f
C1979 DIV_P FS_P_GATE 0.03141f
C1980 TERM_LS_P_S TERM_OR_P_B 0.45674f
C1981 VDD PULLDOWN_N 0.45423f
C1982 TERM_TRIM1 HS_P_2 0.04571f
C1983 FS_N_OUT HS_N_6 0.09249f
C1984 HS_N RX_N 0.31917f
C1985 TERM_GATE_N_BLEED_5 PULLDOWN_N_R 0.00251f
C1986 TERM_TRIM1 HS_P_1 0.05414f
C1987 PULLUP_N_BLEED_5 PULLDOWN_N_R 0.03764f
C1988 PULLUP_N_GATE TERM_P_R 0.8077f
C1989 HS_PBIAS FS_N_BLEED_0 0.00345f
C1990 RX_N PULLUP_P_CONTROL_S 0.05659f
C1991 PAD_N FS_N_WELL 1.67653f
C1992 PULLDOWN_N_R FS_N_BLEED_2 0.05831f
C1993 HS_N_8 DIV_LOW_P 0.02858f
C1994 TERM_GATE_P_BLEED_2 HS_P_4 0.03169f
C1995 PULLUP_N PULLUP_N_OUT 0.00105f
C1996 TERM_GATE_N_BLEED_3 HS_N_10 0.04007f
C1997 PULLUP_N_BLEED_6 PULLDOWN_N_R 0.036f
C1998 HS_N VDD 1.96972f
C1999 PULLUP_P_OUT HS_N_3 0.02404f
C2000 TERM_ENABLE HS_N_3 0.04571f
C2001 HS_N_2 HS_N_6 0.07979f
C2002 TERM_GATE_P_BLEED_2 HS_P_9 0.04573f
C2003 FS_P_BLEED_4 HS_N_6 0.03931f
C2004 TERM_TRIM2 FS_N_BLEED_6 0.04124f
C2005 TERM_GATE_N_BLEED_1 TERM_VCM 0.04848f
C2006 HS_P_5 TERM_GATE_N 0.02846f
C2007 TERM_GATE_N HS_N_0 0.02689f
C2008 VDD PULLUP_P_CONTROL_S 0.62495f
C2009 FS_P_BLEED_6 HS_N_13 0.03931f
C2010 HS_PBIAS HS_N_9 2.71073f
C2011 TERM_GATE_P_BLEED_1 TERM_GATE_P 0.00131f
C2012 RX_P FS_N_CONTROL_S 0.03266f
C2013 TERM_GATE_P_BLEED_1 HS_N_12 0.03973f
C2014 HS_N_1 HS_N_13 0.11273f
C2015 HS_P_4 HS_N_7 0.03673f
C2016 HS_PBIAS FS_HIGH_P 0.22555f
C2017 FS_P_GATE HS_N_13 0.07491f
C2018 LS_SLOW FS_N_CONTROL_S 0.00299f
C2019 DIV_P TERM_OR_P_S 0.00776f
C2020 HS_P_4 PAD_P 1.33912f
C2021 PULLUP_P TERM_GATE_N_BLEED_5 0.82704f
C2022 PULLUP_P PULLUP_N_BLEED_5 0.83162f
C2023 RX_N HS_N_1 0.08135f
C2024 HS_P_12 HS_N_13 0.06892f
C2025 HS_P_9 HS_N_7 0.03586f
C2026 HS_N_9 HS_N_11 0.00926f
C2027 RX_N FS_P_GATE 0.11482f
C2028 HS_P_9 PAD_P 2.15614f
C2029 TERM_GATE_P HS_N_3 0.03931f
C2030 TERM_GATE_P_BLEED_6 LSNB 0.04828f
C2031 HS_N_11 FS_HIGH_P 0.04429f
C2032 HS_N_12 HS_N_3 0.02997f
C2033 VDD FS_P_BLEED_6 0
C2034 VCM_LOW_OK HS_N_6 0.02458f
C2035 PULLUP_N_OUT FS_N_CTLX 0.25263f
C2036 DIV_ENABLE FS_N_BLEED_0 0
C2037 BYPASS_ENABLE HS_P_0 0
C2038 TERM_TRIM1 LSNB 0.08569f
C2039 TERM_GATE_P_BLEED_2 TERM_GATE_P_BLEED_1 0.034f
C2040 TERM_OR_N_S HS_N_13 0.02404f
C2041 VDD HS_N_1 5.93219f
C2042 VDD FS_P_GATE 19.9783f
C2043 TERM_TRIM0 LSM_L_N 0.05476f
C2044 RX_P PULLUP_N_WELL 0.18464f
C2045 RX_N TERM_OR_N_S 0.09329f
C2046 HS_PBIAS PULLUP_N 0.02682f
C2047 LS_SLOW_B FS_N_CONTROL_S 0.51612f
C2048 TERM_OR_N_B HS_N_6 0.05882f
C2049 LS_SLOW PULLUP_N_WELL 0.25381f
C2050 VDD HS_P_12 6.31499f
C2051 TERM_TRIM0 TERM_GATE_N 0.19504f
C2052 RX_P HS_N_10 0.03692f
C2053 TERM_OR_P_S HS_N_13 0.04174f
C2054 TERM_TRIM1 FS_LOW_N 0.02404f
C2055 HS_N_5 HS_N_10 0
C2056 LS_SLOW HS_N_10 0.00299f
C2057 PULLUP_P_WELL HS_N_13 0.16079f
C2058 FS_LOW_P TERM_P_R 0.15389f
C2059 TERM_GATE_P_BLEED_1 HS_N_7 0.05151f
C2060 HS_P_8 PULLUP_P_OUT 0.04829f
C2061 TERM_TRIM1 TERM_OR_P_B 0.02844f
C2062 HS_P_8 TERM_ENABLE 0.04571f
C2063 DIV_ENABLE HS_N_9 0.03888f
C2064 HS_P_0 HS_P_6 0.05883f
C2065 HS_N HS_P 2.06085f
C2066 DIV_N TERM_P_R 0.13473f
C2067 VDD TERM_OR_N_S 10.7362f
C2068 RX_N PULLUP_P_WELL 0.08452f
C2069 DIV_ENABLE FS_HIGH_P 1.32331f
C2070 RX_P FS_N_WELL 0.25839f
C2071 HS_N_5 FS_N_WELL 0.10488f
C2072 PULLUP_P_GATE HS_N_3 0.07211f
C2073 LS_SLOW FS_N_WELL 1.08401f
C2074 FS_LOW_P PULLDOWN_P_R 0.05833f
C2075 PAD_N HS_N 37.0326f
C2076 HS_P_4 PULLDOWN_N_R 0.02404f
C2077 FS_P_BLEED_1 FS_N_WELL 0.21014f
C2078 HS_N_7 HS_N_3 0.04079f
C2079 FS_N_BLEED_6 PULLUP_N_OUT 0.06315f
C2080 VDD TERM_OR_P_NS 0.69905f
C2081 VDD TERM_OR_P_S 4.43437f
C2082 VDD FS_P_BLEED_3 0.38284f
C2083 FS_LOW_P FS_P_BLEED_5 0.0781f
C2084 PULLUP_N_WELL LS_SLOW_B 0.02955f
C2085 HS_N_3 PAD_P 0.05876f
C2086 HS_N_9 TERM_N_R 0.08666f
C2087 VDD PULLUP_P_WELL 11.8193f
C2088 HS_P_9 PULLDOWN_N_R 4.34463f
C2089 DIV_N FS_P_BLEED_5 0
C2090 LSM_H_P TERM_N_R 0.05543f
C2091 HS_P_8 TERM_GATE_P 0.09149f
C2092 TERM_N_R FS_HIGH_P 0.20134f
C2093 HS_P_11 HS_N_10 0.04138f
C2094 HS_PBIAS FS_N_CTLX 0.02965f
C2095 PULLUP_P_BLEED_3 FS_N_GATE 0.05515f
C2096 FS_HIGH_N FS_N_CONTROL_S 0.58773f
C2097 TERM_TRIM0 TERM_GATE_P_BLEED_5 0.02567f
C2098 TERM_VCM PULLUP_P_BLEED_4 0.00196f
C2099 RX_N DIV_P 0.31854f
C2100 HS_N_9 HS_N_8 83.1284f
C2101 FS_P_BLEED_6 HS_P 0.10818f
C2102 HS_N TERM_GATE_N_BLEED_3 0.33695f
C2103 TERM_GATE_P_BLEED_0 HS_N_10 0
C2104 HS_N_1 HS_P 0.75164f
C2105 TERM_VCM FS_N_OUT 4.83001f
C2106 RX_P FS_N_BLEED_3 0.00418f
C2107 HS_N_8 FS_HIGH_P 0.04403f
C2108 FS_N_GATE TERM_P_R 0.17343f
C2109 LS_SLOW_B FS_N_WELL 2.00671f
C2110 HS_P_11 FS_N_WELL 0.05123f
C2111 FS_P_GATE HS_P 0.32888f
C2112 PULLUP_N_OUT PULLUP_N_BLEED_3 0
C2113 FS_N_OUT FS_P_WELL 82.0584f
C2114 LS_SLOW FS_N_BLEED_3 0
C2115 HS_P_12 HS_P 1.99001f
C2116 HS_P_2 HS_N_0 0.03425f
C2117 HS_P_5 HS_P_2 0.03142f
C2118 VDD DIV_P 0.29981f
C2119 HS_P_8 TERM_GATE_P_BLEED_2 0.03396f
C2120 PAD_N HS_N_1 1.40149f
C2121 HS_P_5 HS_P_1 0.03097f
C2122 PULLUP_P_BLEED_1 FS_N_OUT 0.85951f
C2123 PULLUP_P_BLEED_6 TERM_ENABLE 0.04531f
C2124 PAD_N FS_P_GATE 0.64937f
C2125 PULLUP_N TERM_N_R 3.60899f
C2126 TERM_TRIM0 FS_P_CTLX 1.99452f
C2127 PAD_N HS_P_12 0.34806f
C2128 TERM_VCM FS_P_BLEED_4 0.03302f
C2129 HS_N_2 FS_P_WELL 0.1391f
C2130 TERM_OR_N_S HS_P 0.02404f
C2131 FS_HIGH_N PULLUP_N_WELL 0.21622f
C2132 FS_P_BLEED_4 FS_P_WELL 0.06813f
C2133 PULLUP_N_WELL PULLUP_N_BLEED_0 0.04685f
C2134 FS_N_BLEED_6 HS_PBIAS 0.04828f
C2135 DIV_ENABLE PULLUP_N_BLEED_2 0
C2136 HS_N_3 PULLDOWN_N_R 0.06832f
C2137 RX_P PULLDOWN_N 0.03489f
C2138 TERM_VCM FS_P_BLEED_2 0.00196f
C2139 PULLUP_P_BLEED_1 HS_N_2 0.03931f
C2140 HS_P_8 PAD_P 1.30726f
C2141 TERM_GATE_N_BLEED_3 HS_N_1 0.04034f
C2142 TERM_VCM LSM_H_N 0.04973f
C2143 LS_SLOW PULLDOWN_N 0.04828f
C2144 HS_P_6 HS_N_4 0.02404f
C2145 TERM_OR_P_S HS_P 0.06479f
C2146 TRIM_N_2_R TERM_N_R 0.0574f
C2147 TERM_GATE_N_BLEED_2 FS_HIGH_P 0.01347f
C2148 PULLUP_P_WELL HS_P 0.1926f
C2149 HS_N_0 PULLDOWN_P 0.02407f
C2150 PULLUP_N_GATE PULLUP_N_WELL 31.9661f
C2151 HS_P_3 FS_N_WELL 0.04908f
C2152 PULLUP_P_BLEED_6 HS_N_12 0.03489f
C2153 TERM_LS_N_S TERM_P_R 1.33002f
C2154 VDD HS_N_13 4.85591f
C2155 FS_HIGH_N FS_N_WELL 5.83291f
C2156 RX_P HS_N 0.18677f
C2157 HS_N HS_N_5 6.37205f
C2158 HS_PBIAS PULLUP_N_BLEED_3 0.09588f
C2159 TERM_VCM VCM_LOW_OK 2.02867f
C2160 HS_P_0 HS_N_6 0
C2161 TERM_TRIM0 HS_P_2 0.03698f
C2162 HS_N LS_SLOW 0.06726f
C2163 VDD RX_N 3.19515f
C2164 VCM_LOW_OK FS_P_WELL 0.09836f
C2165 TERM_TRIM0 HS_P_1 0.03743f
C2166 TERM_N_R FS_N_CTLX 0.05957f
C2167 PULLUP_P_BLEED_5 TERM_TRIM1 0.12493f
C2168 RX_P PULLUP_P_CONTROL_S 0.03846f
C2169 LS_SLOW PULLUP_P_CONTROL_S 0.11069f
C2170 TERM_GATE_N_BLEED_1 HS_N_3 0.03931f
C2171 TERM_GATE_N HS_N_9 0.05301f
C2172 TERM_VCM TERM_OR_N_B 0.03637f
C2173 HS_P_5 LSNB 0.00776f
C2174 LSNB HS_N_0 0.05939f
C2175 TERM_GATE_N LSM_H_P 0.02493f
C2176 HS_P_2 DIV_LOW_P 0.00416f
C2177 HS_P_1 DIV_LOW_P 0.08094f
C2178 PULLUP_N_GATE FS_N_WELL 0.33699f
C2179 PULLUP_P HS_N_3 0.0397f
C2180 TERM_TRIM2 LSM_L_P 0.03533f
C2181 DIV_P HS_P 0.08005f
C2182 TERM_GATE_N_BLEED_4 HS_N_7 0
C2183 DIV_ENABLE FS_N_BLEED_6 0.03564f
C2184 PULLUP_N_WELL FS_N_BLEED_4 0.00106f
C2185 HS_P_7 PULLUP_N_OUT 0.00322f
C2186 PULLUP_N PULLUP_N_BLEED_4 0.93f
C2187 FS_LOW_N HS_N_0 0.08965f
C2188 TERM_ENABLE PULLUP_N_BLEED_1 0.04379f
C2189 PULLUP_P_GATE PULLUP_P_BLEED_6 5.01134f
C2190 PAD_N DIV_P 0.57332f
C2191 HS_N HS_P_11 0.67178f
C2192 FS_P_BLEED_6 HS_N_5 0.04559f
C2193 HS_N_0 TERM_OR_P_B 0.03532f
C2194 HS_P_5 TERM_OR_P_B 0.05591f
C2195 PULLUP_P_BLEED_6 HS_N_7 0.03489f
C2196 VDD TRIM_N_0_R 0
C2197 RX_P HS_N_1 0.0416f
C2198 HS_P_8 PULLDOWN_N_R 0.07217f
C2199 PULLUP_N_CONTROL_S PULLUP_N_OUT 0
C2200 HS_N_5 HS_N_1 0.04026f
C2201 PULLUP_P_CONTROL_S LS_SLOW_B 0.19145f
C2202 RX_P FS_P_GATE 0.15668f
C2203 HS_N HS_P_13 0.23649f
C2204 HS_N_5 FS_P_GATE 0.10347f
C2205 LSM_H_N FS_N_BLEED_5 0.00219f
C2206 FS_N_BLEED_6 TERM_N_R 1.57357f
C2207 LS_SLOW FS_P_GATE 0.05578f
C2208 HS_P_7 HS_P_10 0.00792f
C2209 HS_N TERM_GATE_P_BLEED_0 0.00755f
C2210 HS_P_4 FS_N_OUT 0.03489f
C2211 HS_P_12 HS_N_5 0.05493f
C2212 FS_N_WELL FS_N_BLEED_4 0.02521f
C2213 FS_P_GATE FS_P_BLEED_1 0.01246f
C2214 FS_P_BLEED_0 FS_P_OUT 0
C2215 HS_N_13 HS_P 0.20501f
C2216 HS_P_9 FS_N_OUT 0.04828f
C2217 TERM_TRIM0 LSNB 0.0459f
C2218 TERM_ENABLE PULLUP_P_OUT 0.06971f
C2219 RX_P TERM_OR_N_S 0.0714f
C2220 TERM_TRIM2 FS_P_CONTROL_S 0.08434f
C2221 HS_N_5 TERM_OR_N_S 0.02404f
C2222 TERM_GATE_P_BLEED_6 TERM_P_R 0.03592f
C2223 RX_N HS_P 0.31882f
C2224 FS_LOW_P PULLUP_N_WELL 0.25989f
C2225 LS_SLOW TERM_OR_N_S 0.08574f
C2226 HS_P_4 HS_N_2 0.03489f
C2227 LSNB DIV_LOW_P 0.86926f
C2228 PAD_N HS_N_13 1.31822f
C2229 TRIM_N_2_R TERM_GATE_N 0
C2230 TERM_TRIM1 TERM_P_R 0.06801f
C2231 FS_LOW_P HS_N_10 0.04608f
C2232 TERM_TRIM0 FS_LOW_N 0.03698f
C2233 HS_P_11 HS_N_1 0.06578f
C2234 HS_N_2 HS_P_9 0.03425f
C2235 HS_P_7 HS_PBIAS 1.66518f
C2236 DIV_N HS_N_10 0.04536f
C2237 PAD_N RX_N 8.80163f
C2238 HS_N HS_P_3 0.21672f
C2239 FS_P_GATE LS_SLOW_B 0.18079f
C2240 HS_P_11 FS_P_GATE 0.02898f
C2241 TERM_OR_P_S HS_N_5 0.04395f
C2242 HS_N_4 HS_N_6 0.07979f
C2243 FS_N_GATE FS_N_CONTROL_S 2.77662f
C2244 TERM_TRIM0 TERM_OR_P_B 0.03698f
C2245 HS_N FS_HIGH_N 0.07352f
C2246 PULLDOWN_P_R TERM_GATE_P_BLEED_6 0.0477f
C2247 RX_P PULLUP_P_WELL 0.06271f
C2248 HS_N_5 PULLUP_P_WELL 0.15407f
C2249 VDD HS_P 1.51484f
C2250 FS_N_BLEED_4 FS_N_BLEED_3 0.03688f
C2251 HS_P_11 HS_P_12 47.6661f
C2252 PULLUP_N_GATE PULLDOWN_N 0.00133f
C2253 HS_P_13 HS_N_1 0.13155f
C2254 TERM_GATE_N_BLEED_4 PULLDOWN_N_R 0.05831f
C2255 LS_SLOW PULLUP_P_WELL 0.08949f
C2256 HS_P_13 FS_P_GATE 0.02916f
C2257 PULLUP_P_OUT TERM_GATE_P 0.09718f
C2258 FS_P_CONTROL_S FS_P_OUT 0.04021f
C2259 TERM_ENABLE TERM_GATE_P 0.10181f
C2260 TERM_GATE_P_BLEED_5 TERM_GATE_P_BLEED_4 0.04635f
C2261 TERM_GATE_P_BLEED_0 HS_N_1 0
C2262 FS_LOW_P FS_N_WELL 0.11542f
C2263 PULLUP_P_OUT HS_N_12 0.02482f
C2264 HS_P_12 HS_P_13 46.9908f
C2265 TERM_GATE_P_BLEED_1 FS_N_OUT 0.10652f
C2266 TERM_GATE_N_BLEED_3 HS_N_13 0.03939f
C2267 TERM_ENABLE HS_N_12 0.06578f
C2268 DIV_N FS_N_WELL 0.17662f
C2269 HS_PBIAS PULLUP_N_CONTROL_S 0.09332f
C2270 PAD_N VDD 4.74793f
C2271 PULLUP_P_BLEED_6 PULLDOWN_N_R 0.05469f
C2272 TERM_OR_N_S LS_SLOW_B 0.11142f
C2273 FS_P_BLEED_0 PULLUP_N_OUT 0.09726f
C2274 PULLUP_N_GATE HS_N 0.12811f
C2275 HS_P_4 VCM_LOW_OK 0.05375f
C2276 HS_N_3 FS_N_OUT 0.04459f
C2277 VCM_LOW_OK HS_P_9 0.11769f
C2278 TERM_GATE_P_BLEED_1 HS_N_2 0.03931f
C2279 LS_SLOW_B TERM_OR_P_NS 0.00597f
C2280 RX_P DIV_P 1.1636f
C2281 PAD_N TRIM_N_0_R 0.26208f
C2282 LSM_L_P HS_P_10 0.03478f
C2283 TERM_OR_P_S HS_P_11 0.00286f
C2284 FS_P_BLEED_3 LS_SLOW_B 0.08219f
C2285 TERM_GATE_N_BLEED_1 TERM_GATE_N_BLEED_4 0.00929f
C2286 PULLUP_P_WELL LS_SLOW_B 0.11537f
C2287 HS_P_2 HS_N_9 0.03089f
C2288 HS_N_12 TERM_GATE_P 0.03931f
C2289 VDD TERM_GATE_N_BLEED_3 0
C2290 HS_N_10 FS_N_GATE 0.04522f
C2291 HS_P_1 HS_N_9 0.0312f
C2292 PULLUP_P_OUT TERM_GATE_P_BLEED_3 0.04934f
C2293 TERM_OR_P_S HS_P_13 0
C2294 HS_P_3 FS_P_GATE 0.03722f
C2295 TERM_VCM HS_P_0 0.00397f
C2296 TERM_ENABLE TERM_GATE_P_BLEED_3 0.00311f
C2297 FS_N_BLEED_6 LSM_L_N 0.06583f
C2298 HS_P_6 HS_P_10 0.08984f
C2299 HS_P_12 HS_P_3 0.05437f
C2300 HS_N_2 HS_N_3 87.2101f
C2301 PULLUP_P_GATE PULLUP_P_OUT 4.58826f
C2302 FS_P_BLEED_4 HS_N_3 0.03931f
C2303 PULLUP_P_GATE TERM_ENABLE 0.05189f
C2304 PULLUP_P_OUT HS_N_7 0.02404f
C2305 PULLUP_P PULLUP_P_BLEED_6 0.05835f
C2306 PULLUP_N_BLEED_4 PULLUP_N_BLEED_3 0.034f
C2307 FS_P_CONTROL_S PULLUP_N_OUT 0.05271f
C2308 FS_N_GATE FS_N_WELL 73.97449f
C2309 TERM_ENABLE HS_N_7 0.03564f
C2310 PULLUP_P_OUT PAD_P 0.3292f
C2311 DIV_LOW_N HS_N_6 0.03894f
C2312 TERM_GATE_P_BLEED_2 TERM_GATE_P 0.17423f
C2313 HS_PBIAS LSM_L_P 0.1602f
C2314 PULLUP_P_BLEED_2 HS_N_9 0.00148f
C2315 TERM_GATE_P_BLEED_3 TERM_GATE_P 0.05217f
C2316 HS_P_7 TERM_N_R 0.10229f
C2317 HS_N_5 HS_N_13 0.10387f
C2318 HS_N_9 PULLDOWN_P 0.05914f
C2319 TERM_GATE_N_BLEED_6 FS_N_WELL 0.02521f
C2320 HS_PBIAS FS_P_BLEED_0 0.01803f
C2321 PAD_N HS_P 3.31965f
C2322 RX_P RX_N 0.20982p
C2323 HS_PBIAS HS_P_6 0.82947f
C2324 RX_N HS_N_5 0.08496f
C2325 DIV_P TERM_GATE_P_BLEED_0 0.01212f
C2326 RX_N LS_SLOW 0.1832f
C2327 PULLUP_P_GATE HS_N_12 0.07249f
C2328 TERM_GATE_P HS_N_7 0.03931f
C2329 VCM_LOW_OK HS_N_3 0.02404f
C2330 FS_LOW_N FS_N_BLEED_0 0.08376f
C2331 PULLUP_N_CONTROL_S TERM_N_R 0.65808f
C2332 PULLDOWN_N_R PULLUP_N_BLEED_1 0.05302f
C2333 HS_P_7 HS_N_8 0.12443f
C2334 RX_N FS_P_BLEED_1 0.00885f
C2335 TERM_GATE_P PAD_P 0.4877f
C2336 HS_N_12 HS_N_7 0.02514f
C2337 FS_N_GATE FS_N_BLEED_3 0.34422f
C2338 HS_N_12 PAD_P 0.1097f
C2339 HS_P_6 HS_N_11 0.02508f
C2340 HS_N_9 LSNB 0.04524f
C2341 HS_N FS_LOW_P 0.05289f
C2342 RX_P VDD 2.33357f
C2343 VDD HS_N_5 5.4804f
C2344 HS_N_3 TERM_OR_N_B 0.05828f
C2345 TERM_GATE_P_BLEED_2 TERM_GATE_P_BLEED_3 0.42508f
C2346 VDD LS_SLOW 8.87068f
C2347 TERM_LS_P_S FS_N_WELL 0.02181f
C2348 LSNB FS_HIGH_P 0.59839f
C2349 DIV_N HS_N 0.0582f
C2350 TERM_LS_N_S FS_N_WELL 0.06032f
C2351 TERM_GATE_N_BLEED_3 HS_P 0.11051f
C2352 PULLUP_P_BLEED_5 TERM_TRIM0 0.02567f
C2353 VDD FS_P_BLEED_1 0.00219f
C2354 BYPASS_ENABLE DIV_ENABLE 49.0364f
C2355 HS_P_11 HS_N_13 0.10072f
C2356 HS_PBIAS FS_P_CONTROL_S 0
C2357 PULLUP_N PULLDOWN_P 26.84f
C2358 FS_LOW_N HS_N_9 0.08963f
C2359 TERM_GATE_P_BLEED_2 HS_N_7 0
C2360 HS_P_13 HS_N_13 0.00251f
C2361 RX_N HS_P_11 0.03937f
C2362 RX_N LS_SLOW_B 0.21627f
C2363 FS_LOW_N FS_HIGH_P 0.11663p
C2364 PULLUP_P_OUT PULLDOWN_N_R 0.04398f
C2365 TERM_ENABLE PULLDOWN_N_R 0.12045f
C2366 HS_N_9 TERM_OR_P_B 0.03132f
C2367 TERM_VCM HS_N_4 0.051f
C2368 HS_N_4 FS_P_WELL 0.14107f
C2369 HS_P_5 TERM_P_R 0.04032f
C2370 PULLUP_P PULLUP_N_BLEED_1 0.06809f
C2371 BYPASS_ENABLE TERM_N_R 0.12382f
C2372 PULLUP_P_GATE HS_N_7 0.07412f
C2373 VDD LS_SLOW_B 5.85491f
C2374 VDD HS_P_11 5.03682f
C2375 FS_LOW_P HS_N_1 0.04618f
C2376 HS_N_7 PAD_P 0.0487f
C2377 PULLUP_P_BLEED_1 HS_N_4 0.04421f
C2378 TERM_VCM TRIM_P_2_R 2.66186f
C2379 VDD HS_P_13 4.74045f
C2380 FS_LOW_P FS_P_GATE 0.13532f
C2381 HS_P_5 PULLDOWN_P_R 0.02463f
C2382 VDD TRIM_N_1_R 0.01274f
C2383 PULLDOWN_P_R HS_N_0 0.03128f
C2384 PULLUP_P_BLEED_6 PULLUP_P_BLEED_4 0.23498f
C2385 DIV_N HS_N_1 0.04536f
C2386 HS_N FS_N_GATE 0.37611f
C2387 TERM_GATE_P PULLDOWN_N_R 0.05677f
C2388 HS_P_10 HS_N_6 0
C2389 DIV_N FS_P_GATE 0.06466f
C2390 FS_LOW_P HS_P_12 0.04574f
C2391 HS_P_0 HS_P_4 0.02411f
C2392 HS_P_8 VCM_LOW_OK 0.09345f
C2393 FS_P_BLEED_5 HS_N_0 0
C2394 FS_P_BLEED_0 TERM_N_R 0.09138f
C2395 PULLUP_P_BLEED_6 FS_N_OUT 0.04421f
C2396 HS_N_12 PULLDOWN_N_R 0.06852f
C2397 TERM_GATE_N_BLEED_1 TERM_GATE_N_BLEED_0 1.41012f
C2398 TERM_GATE_N_BLEED_1 TERM_ENABLE 0.04379f
C2399 PULLUP_P_BLEED_1 PULLUP_P_BLEED_0 0.05305f
C2400 FS_HIGH_N HS_N_13 0.10357f
C2401 PULLUP_P_CONTROL_S FS_N_GATE 0.00136f
C2402 PULLDOWN_P FS_N_CTLX 0.04785f
C2403 HS_P_0 HS_P_9 0.07995f
C2404 PULLUP_P PULLUP_P_OUT 0.00215f
C2405 PULLUP_P TERM_ENABLE 0.04484f
C2406 TERM_TRIM1 PULLUP_N_WELL 0.13446f
C2407 TERM_GATE_P_BLEED_6 HS_N_10 0.03489f
C2408 RX_N HS_P_3 0.03722f
C2409 RX_P HS_P 0.18655f
C2410 TRIM_N_1_R TRIM_N_0_R 0.05735f
C2411 HS_N_5 HS_P 0.99454f
C2412 RX_N FS_HIGH_N 0.03494f
C2413 FS_LOW_P TERM_OR_N_S 0.05192f
C2414 FS_P_BLEED_0 HS_N_8 0.00108f
C2415 LS_SLOW HS_P 0.04428f
C2416 DIV_N TERM_OR_N_S 0.06087f
C2417 HS_P_6 HS_N_8 0.0311f
C2418 PULLUP_P_BLEED_6 HS_N_2 0.03489f
C2419 TERM_TRIM0 TERM_P_R 0.08745f
C2420 TERM_TRIM2 TERM_VCM 0.17833p
C2421 PAD_N RX_P 1.30882f
C2422 TERM_GATE_P_BLEED_2 PULLDOWN_N_R 0.06216f
C2423 PAD_N HS_N_5 1.32747f
C2424 TERM_GATE_P_BLEED_6 FS_N_WELL 0.0618f
C2425 TERM_TRIM2 FS_P_WELL 0.10129f
C2426 LSNB FS_N_CTLX 0.44024f
C2427 FS_LOW_P TERM_OR_P_NS 0.48053f
C2428 FS_LOW_P TERM_OR_P_S 0.53664f
C2429 VDD HS_P_3 5.01086f
C2430 HS_PBIAS HS_N_6 3.28974f
C2431 VDD FS_HIGH_N 1.65246f
C2432 FS_LOW_P PULLUP_P_WELL 0.34416f
C2433 TERM_GATE_N_BLEED_1 HS_N_12 0.03931f
C2434 VDD PULLUP_N_BLEED_0 1.03595f
C2435 TERM_GATE_P_BLEED_3 PULLDOWN_N_R 0.00251f
C2436 DIV_N TERM_OR_P_S 0
C2437 TERM_TRIM1 FS_N_WELL 0.2155f
C2438 FS_P_CONTROL_S TERM_N_R 0.05944f
C2439 PULLUP_N_GATE RX_N 0.18007f
C2440 TERM_VCM DIV_LOW_N 0.04093f
C2441 DIV_N PULLUP_P_WELL 0.22381f
C2442 FS_LOW_N PULLUP_N_BLEED_2 0.08389f
C2443 HS_N_1 FS_N_GATE 0.0359f
C2444 PULLUP_P HS_N_12 0.04655f
C2445 PULLUP_P_GATE PULLDOWN_N_R 0.17941f
C2446 FS_P_GATE FS_N_GATE 0.05565f
C2447 HS_P_0 TERM_GATE_P_BLEED_1 0.03856f
C2448 HS_N_11 HS_N_6 0.0742f
C2449 FS_N_BLEED_6 PULLDOWN_P 0.37855f
C2450 TERM_GATE_N_BLEED_5 DIV_LOW_N 0.0078f
C2451 TERM_VCM FS_P_OUT 0.69023f
C2452 HS_N_7 PULLDOWN_N_R 0.02404f
C2453 LS_SLOW_B HS_P 0.0019f
C2454 HS_P_11 HS_P 7.42218f
C2455 FS_P_OUT FS_P_WELL 59.1629f
C2456 PULLDOWN_N_R PAD_P 2.18431f
C2457 HS_N_5 TERM_GATE_N_BLEED_3 0.0458f
C2458 PULLUP_N_BLEED_6 TERM_TRIM2 0.00333f
C2459 PULLUP_N_GATE VDD 7.74866f
C2460 PULLUP_P_BLEED_6 VCM_LOW_OK 1.56765f
C2461 HS_P_13 HS_P 2.06776f
C2462 PAD_N HS_P_11 2.7539f
C2463 TERM_OR_N_S FS_N_GATE 2.71374f
C2464 FS_LOW_P DIV_P 2.18915f
C2465 PULLUP_P_BLEED_6 TERM_OR_N_B 0
C2466 PAD_N HS_P_13 0.8397f
C2467 DIV_N DIV_P 45.7841f
C2468 RX_N FS_N_BLEED_4 0.08699f
C2469 PAD_N TRIM_N_1_R 0.52916f
C2470 HS_P_4 HS_N_4 0.12555f
C2471 TERM_GATE_N_BLEED_1 HS_N_7 0.03931f
C2472 PULLUP_P_WELL FS_N_GATE 0.08643f
C2473 PULLUP_P_GATE PULLUP_P 1.21432f
C2474 DIV_ENABLE HS_N_6 0.0366f
C2475 FS_N_BLEED_6 FS_LOW_N 0.07127f
C2476 TERM_TRIM2 FS_N_BLEED_5 0.06247f
C2477 VDD FS_N_BLEED_4 0.00251f
C2478 HS_P_9 HS_N_4 0.03425f
C2479 HS_P_3 HS_P 0.60794f
C2480 FS_HIGH_N HS_P 0.05849f
C2481 TERM_ENABLE PULLUP_P_BLEED_4 0.0503f
C2482 TERM_VCM PULLUP_N_OUT 0.12025f
C2483 PULLUP_P_OUT FS_N_OUT 0.10577f
C2484 HS_PBIAS DIFF_ENABLE 0.1887f
C2485 PULLUP_N_OUT FS_P_WELL 0.11933f
C2486 TERM_ENABLE FS_N_OUT 0.03489f
C2487 FS_LOW_P HS_N_13 0.17017f
C2488 TERM_TRIM1 PULLDOWN_N 0.03489f
C2489 PAD_N HS_P_3 0.56719f
C2490 DIV_N HS_N_13 0.04536f
C2491 TERM_LS_N_S TERM_OR_N_S 0
C2492 RX_P HS_N_5 0.07654f
C2493 TERM_GATE_N_BLEED_5 PULLUP_N_OUT 0.05203f
C2494 FS_LOW_P RX_N 0.0386f
C2495 RX_P LS_SLOW 1.81319f
C2496 LS_SLOW HS_N_5 0.04428f
C2497 DIV_P FS_N_GATE 0.04275f
C2498 HS_N TERM_GATE_P_BLEED_6 0.04122f
C2499 RX_P FS_P_BLEED_1 0.00418f
C2500 DIV_N RX_N 1.37963f
C2501 PULLUP_N_GATE HS_P 0.07544f
C2502 PULLUP_N_OUT FS_N_BLEED_2 0
C2503 LS_SLOW FS_P_BLEED_1 0
C2504 HS_N_8 HS_N_6 0.00206f
C2505 HS_P_7 HS_P_2 0.03109f
C2506 TERM_VCM HS_P_10 0.05762f
C2507 PULLUP_P_OUT HS_N_2 0.02451f
C2508 HS_P_1 HS_P_7 0.03089f
C2509 HS_P_0 HS_P_8 0.02404f
C2510 TERM_ENABLE HS_N_2 0.03489f
C2511 HS_N TERM_TRIM1 0.37452f
C2512 TERM_GATE_N FS_P_CONTROL_S 0.03089f
C2513 FS_P_BLEED_4 PULLUP_P_OUT 0.05824f
C2514 TERM_GATE_P_BLEED_1 HS_N_4 0.04421f
C2515 FS_P_BLEED_4 TERM_ENABLE 0.04507f
C2516 TERM_GATE_P FS_N_OUT 0.11161f
C2517 FS_LOW_P VDD 3.11672f
C2518 TERM_TRIM1 PULLUP_P_CONTROL_S 0.03134f
C2519 DIV_N VDD 1.12551f
C2520 HS_N_12 FS_N_OUT 0.04836f
C2521 FS_P_BLEED_2 PULLUP_P_OUT 0.0517f
C2522 TERM_TRIM2 HS_P_9 0.07775f
C2523 TERM_ENABLE FS_P_BLEED_2 0.0503f
C2524 TERM_GATE_N_BLEED_1 PULLDOWN_N_R 0.05302f
C2525 TERM_ENABLE LSM_H_N 0.04182f
C2526 HS_N_3 HS_N_4 86.48621f
C2527 HS_N_9 TERM_P_R 0.13199f
C2528 RX_P LS_SLOW_B 0.13787f
C2529 RX_P HS_P_11 0.04185f
C2530 HS_N_5 LS_SLOW_B 0.05722f
C2531 HS_P_11 HS_N_5 0.06578f
C2532 LSM_H_P TERM_P_R 0.21581f
C2533 TERM_P_R FS_HIGH_P 0.02905f
C2534 LS_SLOW LS_SLOW_B 4.34526f
C2535 PULLUP_P PULLDOWN_N_R 0.05768f
C2536 HS_N_2 TERM_GATE_P 0.09149f
C2537 FS_N_GATE HS_N_13 0.00133f
C2538 LSM_L_P FS_P_CTLX 0.03631f
C2539 HS_P_4 FS_P_OUT 0.0359f
C2540 DIV_ENABLE DIFF_ENABLE 65.5323f
C2541 HS_N_10 HS_N_0 2.15474f
C2542 HS_N_5 HS_P_13 0.03089f
C2543 TERM_VCM HS_PBIAS 0.25172f
C2544 HS_P_5 HS_N_10 0.02545f
C2545 HS_N_12 HS_N_2 0.00206f
C2546 HS_PBIAS FS_P_WELL 0.42206f
C2547 FS_P_BLEED_4 HS_N_12 0.03931f
C2548 VCM_LOW_OK PULLUP_P_OUT 0.11478f
C2549 TERM_GATE_P_BLEED_6 HS_N_1 0.03489f
C2550 VCM_LOW_OK TERM_ENABLE 0.37504f
C2551 HS_P_9 FS_P_OUT 0.04021f
C2552 FS_P_GATE TERM_GATE_P_BLEED_6 0.04153f
C2553 RX_N FS_N_GATE 0.22129f
C2554 PULLDOWN_P_R HS_N_9 0.03024f
C2555 TRIM_P_0_R TRIM_P_1_R 0.05735f
C2556 PULLDOWN_P_R LSM_H_P 0.0302f
C2557 PULLDOWN_P_R FS_HIGH_P 0.05815f
C2558 HS_P_12 TERM_GATE_P_BLEED_6 0.03489f
C2559 TERM_TRIM1 FS_P_GATE 0.1038f
C2560 TERM_VCM HS_N_11 0.051f
C2561 HS_PBIAS PULLUP_P_BLEED_1 0.09581f
C2562 FS_P_BLEED_5 FS_HIGH_P 0.03577f
C2563 PULLUP_N_CONTROL_S PULLDOWN_P 0.03106f
C2564 HS_P_5 FS_N_WELL 0.05123f
C2565 HS_N_11 FS_P_WELL 0.15537f
C2566 TERM_ENABLE TERM_OR_N_B 2.07581f
C2567 HS_PBIAS FS_N_BLEED_2 0.01803f
C2568 DIFF_ENABLE TERM_N_R 6.2754f
C2569 PULLUP_P_GATE FS_N_OUT 0.15821f
C2570 RX_N TERM_GATE_N_BLEED_6 0.08669f
C2571 VDD FS_N_GATE 18.6665f
C2572 HS_N_7 FS_N_OUT 0.06669f
C2573 TERM_GATE_N_BLEED_1 PULLUP_P 0.05798f
C2574 PULLUP_N TERM_P_R 0.14401f
C2575 FS_N_OUT PAD_P 1.40993f
C2576 PULLUP_P_BLEED_1 HS_N_11 0.03989f
C2577 VCM_LOW_OK TERM_GATE_P 1.22371f
C2578 RX_P HS_P_3 0.03089f
C2579 HS_P_11 HS_P_13 0.00206f
C2580 HS_P_3 HS_N_5 0.03983f
C2581 TERM_TRIM1 TERM_OR_N_S 0.0684f
C2582 VCM_LOW_OK HS_N_12 0.02404f
C2583 RX_P FS_HIGH_N 0.02404f
C2584 TERM_GATE_N HS_N_6 0.02404f
C2585 TERM_TRIM0 PULLUP_N_WELL 0.33749f
C2586 FS_LOW_P HS_P 0.04574f
C2587 LS_SLOW HS_P_3 0.04428f
C2588 VDD TERM_GATE_N_BLEED_6 0.00317f
C2589 LS_SLOW FS_HIGH_N 0.03494f
C2590 PULLUP_P_GATE HS_N_2 0.07211f
C2591 FS_P_CONTROL_S FS_P_CTLX 2.00288f
C2592 PULLUP_P_GATE FS_P_BLEED_4 0
C2593 DIV_N HS_P 0.05257f
C2594 HS_N_2 HS_N_7 0.04068f
C2595 HS_P_7 TERM_OR_P_B 0.05552f
C2596 HS_P_6 HS_P_2 0.05935f
C2597 HS_N_12 TERM_OR_N_B 0.05846f
C2598 FS_P_BLEED_4 HS_N_7 0.03931f
C2599 TERM_TRIM1 TERM_OR_P_NS 0.03638f
C2600 HS_N_3 DIV_LOW_N 0.03894f
C2601 TERM_TRIM1 FS_P_BLEED_3 0.1547f
C2602 HS_P_1 HS_P_6 0.05935f
C2603 RX_N TERM_LS_P_S 0.04858f
C2604 HS_N_2 PAD_P 2.34009f
C2605 RX_N TERM_LS_N_S 0.04975f
C2606 TERM_TRIM1 PULLUP_P_WELL 0.06271f
C2607 DIV_ENABLE FS_P_WELL 0.1408f
C2608 HS_P_9 PULLUP_N_OUT 0.05444f
C2609 HS_N_10 DIV_LOW_P 0.02915f
C2610 PAD_N DIV_N 6.40437f
C2611 PULLUP_N_GATE RX_P 0.12223f
C2612 TERM_GATE_P_BLEED_2 VCM_LOW_OK 0.85312f
C2613 TERM_TRIM0 FS_N_WELL 0.32269f
C2614 PULLUP_N_GATE LS_SLOW 0.13354f
C2615 PULLUP_N_BLEED_2 TERM_P_R 0.00257f
C2616 VDD TERM_LS_P_S 6.61497f
C2617 VDD TERM_LS_N_S 6.99409f
C2618 VCM_LOW_OK TERM_GATE_P_BLEED_3 0.04916f
C2619 TERM_P_R FS_N_CTLX 1.99612f
C2620 HS_P_4 HS_P_10 0.04814f
C2621 HS_P_3 LS_SLOW_B 0.05722f
C2622 HS_P_11 HS_P_3 0.04493f
C2623 TERM_VCM TERM_N_R 28.2277f
C2624 FS_HIGH_N LS_SLOW_B 0.05251f
C2625 TERM_N_R FS_P_WELL 0.10588f
C2626 PULLUP_P_GATE VCM_LOW_OK 0.09704f
C2627 DIV_P TERM_GATE_P_BLEED_6 0.15484f
C2628 HS_P_10 HS_P_9 0.04658f
C2629 HS_P_3 HS_P_13 0.26834f
C2630 DIV_N TERM_GATE_N_BLEED_3 0.03851f
C2631 TERM_GATE_N_BLEED_5 TERM_N_R 0.08885f
C2632 VCM_LOW_OK HS_N_7 0.02473f
C2633 PULLUP_N_BLEED_5 TERM_N_R 0.08885f
C2634 TERM_TRIM1 DIV_P 0.05465f
C2635 FS_N_GATE HS_P 0.29983f
C2636 PULLDOWN_N_R FS_N_OUT 0.05508f
C2637 TERM_VCM HS_N_8 0
C2638 PULLUP_P_GATE TERM_OR_N_B 0.01226f
C2639 LSM_L_P LSNB 0.00483f
C2640 HS_N_8 FS_P_WELL 0.14924f
C2641 TERM_N_R FS_N_BLEED_2 0.8419f
C2642 RX_P FS_N_BLEED_4 0.05373f
C2643 HS_N_7 TERM_OR_N_B 0.05896f
C2644 PULLUP_N_GATE LS_SLOW_B 0.11996f
C2645 LS_SLOW FS_N_BLEED_4 0.04881f
C2646 TERM_TRIM2 HS_P_8 0.09292f
C2647 PAD_N FS_N_GATE 1.53406f
C2648 HS_PBIAS HS_P_4 3.82846f
C2649 HS_N HS_N_0 97.2751f
C2650 HS_N HS_P_5 0.38073f
C2651 PULLUP_P_BLEED_1 HS_N_8 0.05643f
C2652 HS_N_2 PULLDOWN_N_R 0.06159f
C2653 PULLUP_P_BLEED_6 HS_N_4 0.03489f
C2654 FS_P_BLEED_4 PULLDOWN_N_R 0.05912f
C2655 FS_N_BLEED_6 TERM_P_R 0.05933f
C2656 FS_N_WELL FS_N_BLEED_1 0.00131f
C2657 HS_PBIAS HS_P_9 5.85509f
C2658 HS_N_3 PULLUP_N_OUT 0.04331f
C2659 TERM_GATE_P_BLEED_6 HS_N_13 0.03489f
C2660 TERM_GATE_P_BLEED_1 HS_P_10 0.01262f
C2661 HS_P_4 HS_N_11 0.03489f
C2662 TERM_GATE_N_BLEED_1 FS_N_OUT 0.04864f
C2663 PULLUP_P_BLEED_6 PULLUP_P_BLEED_0 0.00257f
C2664 HS_P_8 FS_P_OUT 0.07368f
C2665 RX_N TERM_GATE_P_BLEED_6 0.04971f
C2666 HS_P_9 HS_N_11 0.03425f
C2667 LSM_H_N PULLDOWN_N_R 0.07497f
C2668 LS_SLOW_B FS_N_BLEED_4 0.23676f
C2669 HS_P_6 TERM_OR_P_B 0.05568f
C2670 HS_P_0 TERM_ENABLE 0.03489f
C2671 TERM_TRIM0 PULLDOWN_N 0.04828f
C2672 TERM_TRIM1 RX_N 0.01097f
C2673 TERM_LS_N_S HS_P 0.03228f
C2674 RX_P FS_LOW_P 0.03226f
C2675 FS_LOW_P HS_N_5 0.04574f
C2676 FS_P_CONTROL_S LSNB 1.20291f
C2677 FS_LOW_P LS_SLOW 0.04565f
C2678 TERM_GATE_N_BLEED_1 HS_N_2 0.03931f
C2679 DIV_N RX_P 0.53686f
C2680 PULLUP_N_BLEED_3 TERM_P_R 0.00257f
C2681 DIV_N HS_N_5 0.04536f
C2682 FS_P_BLEED_6 HS_N_0 0.04058f
C2683 PULLUP_N_GATE FS_HIGH_N 0.0026f
C2684 VDD TERM_GATE_P_BLEED_6 0.42599f
C2685 VCM_LOW_OK PULLDOWN_N_R 0.12509f
C2686 DIV_N LS_SLOW 0.04709f
C2687 HS_P_5 HS_N_1 0.02599f
C2688 HS_N_1 HS_N_0 88.99139f
C2689 PULLUP_P HS_N_2 0
C2690 FS_P_GATE HS_N_0 0.07696f
C2691 HS_P_5 FS_P_GATE 0.02898f
C2692 HS_PBIAS TERM_GATE_P_BLEED_1 0.09224f
C2693 PULLUP_N_BLEED_5 PULLUP_N_BLEED_4 0.06051f
C2694 HS_P_1 HS_N_6 0
C2695 VDD TERM_TRIM1 2.92363f
C2696 HS_N TERM_TRIM0 0.22985f
C2697 HS_P_5 HS_P_12 0.02866f
C2698 TERM_VCM LSM_L_N 0.04973f
C2699 HS_P_12 HS_N_0 0.06005f
C2700 TERM_GATE_N_BLEED_4 DIV_LOW_N 0.00808f
C2701 HS_P_0 TERM_GATE_P 0.03931f
C2702 PULLDOWN_N_R TERM_OR_N_B 0.16074f
C2703 DIV_ENABLE HS_P_4 0.00568f
C2704 FS_N_WELL FS_N_BLEED_0 0.96553f
C2705 TERM_TRIM2 PULLUP_P_BLEED_6 0.04294f
C2706 TERM_TRIM0 PULLUP_P_CONTROL_S 0.0414f
C2707 TERM_VCM TERM_GATE_N 8.65734f
C2708 PULLUP_N_WELL FS_HIGH_P 0.20656f
C2709 TERM_GATE_N FS_P_WELL 0.0941f
C2710 HS_N DIV_LOW_P 0.04799f
C2711 TERM_GATE_P_BLEED_1 HS_N_11 0.03985f
C2712 HS_N_9 HS_N_10 0.07322f
C2713 PULLUP_P LSM_H_N 0.05662f
C2714 HS_PBIAS HS_N_3 4.87029f
C2715 TERM_TRIM1 TRIM_N_0_R 0
C2716 TERM_OR_N_S HS_N_0 0.02404f
C2717 HS_N_10 FS_HIGH_P 0.04435f
C2718 TERM_GATE_N TERM_GATE_N_BLEED_5 0.8327f
C2719 FS_LOW_P LS_SLOW_B 0.0591f
C2720 FS_LOW_P HS_P_11 0.17009f
C2721 HS_P_8 PULLUP_N_OUT 0.04721f
C2722 PULLUP_P_BLEED_2 HS_N_6 0
C2723 DIV_N LS_SLOW_B 0.05859f
C2724 DIV_N HS_P_11 0.00487f
C2725 HS_P_4 TERM_N_R 0.03095f
C2726 FS_LOW_P HS_P_13 0.04566f
C2727 HS_N_3 HS_N_11 0.03009f
C2728 HS_N_6 PULLDOWN_P 0.02404f
C2729 HS_N_9 FS_N_WELL 0.05123f
C2730 RX_P FS_N_GATE 0.1843f
C2731 PULLUP_P VCM_LOW_OK 0.04943f
C2732 HS_N_5 FS_N_GATE 0.0924f
C2733 HS_P_9 TERM_N_R 0.03089f
C2734 HS_P_0 TERM_GATE_P_BLEED_2 0.00802f
C2735 FS_LOW_P TERM_GATE_P_BLEED_0 0.0781f
C2736 LSM_H_P FS_N_WELL 0.06636f
C2737 TERM_OR_P_S HS_N_0 0.04215f
C2738 LS_SLOW FS_N_GATE 0.17028f
C2739 FS_N_WELL FS_HIGH_P 0.09332f
C2740 PULLUP_P_WELL HS_N_0 0.28646f
C2741 DIV_N TERM_GATE_P_BLEED_0 0
C2742 FS_P_BLEED_1 FS_N_GATE 0.82412f
C2743 HS_P_4 HS_N_8 0.06578f
C2744 HS_P_8 HS_P_10 0.00817f
C2745 TERM_TRIM0 FS_P_GATE 0.115f
C2746 PULLUP_N PULLUP_N_WELL 0.1165f
C2747 PULLUP_P TERM_OR_N_B 0.04745f
C2748 RX_P TERM_GATE_N_BLEED_6 0.05342f
C2749 HS_N FS_N_BLEED_1 0.35035f
C2750 HS_P_9 HS_N_8 0.03425f
C2751 HS_N_1 DIV_LOW_P 0.02938f
C2752 LSNB HS_N_6 0.09352f
C2753 LS_SLOW TERM_GATE_N_BLEED_6 0.12971f
C2754 FS_N_CONTROL_S FS_N_CTLX 2.79468f
C2755 HS_P_0 HS_N_7 0.03445f
C2756 TERM_GATE_P_BLEED_6 HS_P 0.03489f
C2757 TERM_GATE_P_BLEED_5 TERM_VCM 0.84584f
C2758 PULLUP_P_OUT HS_N_4 0.02404f
C2759 HS_P_0 PAD_P 1.68417f
C2760 TERM_ENABLE HS_N_4 0.06335f
C2761 HS_P_12 DIV_LOW_P 0.0346f
C2762 TERM_GATE_P_BLEED_4 FS_N_WELL 0.00856f
C2763 TERM_TRIM1 HS_P 0.37457f
C2764 TERM_TRIM0 TERM_OR_N_S 0.08464f
C2765 FS_LOW_P HS_P_3 0.04566f
C2766 TERM_GATE_N_BLEED_4 PULLUP_N_OUT 0
C2767 FS_LOW_P FS_HIGH_N 0.11473f
C2768 HS_P_7 TERM_P_R 0.16834f
C2769 DIV_ENABLE HS_N_3 0.03489f
C2770 FS_LOW_N HS_N_6 0.13136f
C2771 LS_SLOW_B FS_N_GATE 0.29477f
C2772 HS_P_11 FS_N_GATE 0.04032f
C2773 DIV_P HS_N_0 0
C2774 TERM_TRIM2 PULLUP_N_BLEED_1 0.04294f
C2775 HS_N_6 TERM_OR_P_B 0.03089f
C2776 HS_P_8 HS_PBIAS 3.49071f
C2777 RX_P TERM_LS_P_S 0.03559f
C2778 PAD_N TERM_TRIM1 1.05408f
C2779 RX_P TERM_LS_N_S 0.03146f
C2780 TERM_LS_N_S HS_N_5 0.00258f
C2781 TERM_TRIM0 TERM_OR_P_NS 0.06413f
C2782 LS_SLOW TERM_LS_P_S 2.26232f
C2783 TERM_TRIM0 FS_P_BLEED_3 0.87857f
C2784 PULLUP_N_WELL PULLUP_N_BLEED_2 0.00616f
C2785 LS_SLOW TERM_LS_N_S 0.43178f
C2786 PULLUP_P_BLEED_6 PULLUP_N_OUT 0.25137f
C2787 TERM_VCM FS_P_CTLX 0.0333f
C2788 TERM_TRIM0 PULLUP_P_WELL 0.08859f
C2789 PULLUP_N_CONTROL_S TERM_P_R 0.05614f
C2790 PULLDOWN_P_R HS_P_7 0.06095f
C2791 TERM_GATE_N_BLEED_6 LS_SLOW_B 0.23591f
C2792 TERM_GATE_P HS_N_4 0.04872f
C2793 TERM_GATE_P_BLEED_1 HS_N_8 0.05643f
C2794 PULLUP_N_GATE FS_LOW_P 0.08058f
C2795 HS_N_3 TERM_N_R 0.03937f
C2796 HS_N_12 HS_N_4 0
C2797 FS_P_BLEED_4 FS_N_OUT 0.03931f
C2798 HS_N FS_N_BLEED_0 0.00799f
C2799 DIFF_ENABLE PULLDOWN_P 0.11011f
C2800 PULLUP_P_BLEED_0 HS_N_12 0
C2801 TRIM_P_2_R TERM_GATE_P 0
C2802 HS_N_8 HS_N_3 0.04068f
C2803 HS_P_5 HS_N_13 0.02464f
C2804 LSM_H_N FS_N_OUT 1.00192f
C2805 HS_N_0 HS_N_13 0.00116f
C2806 TERM_TRIM2 TERM_ENABLE 0.01656f
C2807 TERM_TRIM2 TERM_GATE_N_BLEED_0 0.05711f
C2808 FS_P_BLEED_4 HS_N_2 0.03931f
C2809 FS_N_WELL FS_N_CTLX 0.0783f
C2810 TERM_LS_P_S LS_SLOW_B 0.18596f
C2811 HS_P_3 FS_N_GATE 0.04275f
C2812 HS_P_4 TERM_GATE_N 0.02404f
C2813 FS_HIGH_N FS_N_GATE 4.98708f
C2814 HS_P_0 PULLDOWN_N_R 0.07177f
C2815 TERM_TRIM0 DIV_P 0.03743f
C2816 RX_N HS_P_5 0.03937f
C2817 HS_N HS_N_9 7.62168f
C2818 TERM_VCM HS_P_2 0.07535f
C2819 HS_PBIAS TERM_GATE_N_BLEED_4 0.01803f
C2820 TERM_ENABLE DIV_LOW_N 0.03302f
C2821 TERM_VCM HS_P_1 0.06114f
C2822 HS_P_2 FS_P_WELL 0.04122f
C2823 TERM_GATE_N HS_P_9 0.03089f
C2824 HS_N FS_HIGH_P 0.05155f
C2825 VCM_LOW_OK FS_N_OUT 0.03336f
C2826 BYPASS_ENABLE TERM_P_R 0.0559f
C2827 FS_N_BLEED_6 PULLUP_N_WELL 0.00261f
C2828 FS_P_BLEED_4 FS_P_BLEED_2 0.22633f
C2829 DIV_P DIV_LOW_P 0.27819f
C2830 PULLUP_P_OUT FS_P_OUT 0.04403f
C2831 PULLUP_P_GATE HS_N_4 0.07212f
C2832 TERM_ENABLE FS_P_OUT 0.05466f
C2833 VDD HS_N_0 4.71062f
C2834 VDD HS_P_5 6.98911f
C2835 HS_PBIAS PULLUP_P_BLEED_6 0.04828f
C2836 HS_N_7 HS_N_4 0.04101f
C2837 TERM_TRIM2 TERM_GATE_P 0.04104f
C2838 LSM_L_P TERM_P_R 1.0058f
C2839 TERM_OR_N_B FS_N_OUT 0.13976f
C2840 PULLDOWN_N PULLUP_N 0.04791f
C2841 DIFF_ENABLE FS_LOW_N 0.28612f
C2842 HS_N_4 PAD_P 0.58454f
C2843 TERM_TRIM2 HS_N_12 0.02846f
C2844 PULLUP_P_GATE PULLUP_P_BLEED_0 0
C2845 FS_P_BLEED_0 TERM_P_R 0.07197f
C2846 VCM_LOW_OK HS_N_2 0.02404f
C2847 FS_P_BLEED_4 VCM_LOW_OK 1.56752f
C2848 HS_P_8 TERM_N_R 0.05692f
C2849 PULLUP_P_BLEED_6 HS_N_11 0.03489f
C2850 PULLUP_N_BLEED_1 PULLUP_N_OUT 0.00358f
C2851 RX_P TERM_GATE_P_BLEED_6 0.04337f
C2852 HS_N_5 TERM_GATE_P_BLEED_6 0.03489f
C2853 HS_N_12 DIV_LOW_N 0.03894f
C2854 FS_N_BLEED_6 FS_N_WELL 0.07278f
C2855 LS_SLOW TERM_GATE_P_BLEED_6 0.05647f
C2856 FS_P_BLEED_6 HS_N_9 0.06172f
C2857 PULLUP_N_WELL PULLUP_N_BLEED_3 0.0029f
C2858 HS_N_2 TERM_OR_N_B 0.05828f
C2859 TRIM_P_2_R PAD_P 1.0633f
C2860 RX_P TERM_TRIM1 0.0413f
C2861 TERM_GATE_P FS_P_OUT 4.08933f
C2862 TERM_TRIM1 HS_N_5 0.0826f
C2863 HS_N_9 HS_N_1 0.03242f
C2864 PULLDOWN_P_R FS_P_BLEED_0 0.1159f
C2865 RX_N TERM_TRIM0 0.01914f
C2866 TERM_TRIM1 LS_SLOW 0.22756f
C2867 FS_P_GATE HS_N_9 0.10447f
C2868 TERM_GATE_N_BLEED_5 PULLDOWN_P 0.00384f
C2869 PULLUP_P_BLEED_2 PULLUP_P_BLEED_1 0.034f
C2870 PULLUP_N_BLEED_5 PULLDOWN_P 0.00345f
C2871 HS_N_13 DIV_LOW_P 0.02846f
C2872 HS_P_8 HS_N_8 0.06771f
C2873 HS_N_1 FS_HIGH_P 0.04445f
C2874 LSM_H_P FS_P_GATE 3.81594f
C2875 PULLDOWN_P_R HS_P_6 0.02404f
C2876 HS_P_12 HS_N_9 0.05493f
C2877 FS_P_GATE FS_HIGH_P 0.898f
C2878 DIV_N FS_LOW_P 1.51443f
C2879 FS_N_GATE FS_N_BLEED_4 0.00224f
C2880 FS_N_BLEED_2 PULLDOWN_P 0.26852f
C2881 HS_P_12 FS_HIGH_P 0.08874f
C2882 TERM_GATE_N HS_N_3 0.02404f
C2883 TERM_VCM LSNB 0.01079f
C2884 LSNB FS_P_WELL 0.46206f
C2885 TRIM_P_0_R TERM_TRIM1 0
C2886 VDD TERM_TRIM0 4.38957f
C2887 PULLUP_P_OUT PULLUP_N_OUT 0.12768f
C2888 TERM_TRIM2 PULLUP_P_GATE 0.03289f
C2889 FS_P_CONTROL_S TERM_P_R 0.03928f
C2890 TERM_ENABLE PULLUP_N_OUT 0.1215f
C2891 HS_N_9 TERM_OR_N_S 0.02404f
C2892 TERM_GATE_P_BLEED_2 FS_P_OUT 0
C2893 TERM_GATE_P_BLEED_6 LS_SLOW_B 0.06842f
C2894 HS_P_11 TERM_GATE_P_BLEED_6 0.03489f
C2895 DIV_ENABLE PULLUP_P_BLEED_6 0.01375f
C2896 FS_N_BLEED_6 FS_N_BLEED_3 0.1071f
C2897 TERM_TRIM1 TRIM_P_1_R 0.34827f
C2898 TERM_OR_N_S FS_HIGH_P 0.12502f
C2899 TERM_TRIM2 PAD_P 0.09205f
C2900 PULLUP_P_BLEED_1 LSNB 0.0079f
C2901 TERM_VCM FS_LOW_N 0.03195f
C2902 HS_N PULLUP_N_BLEED_2 0.02215f
C2903 TERM_GATE_N_BLEED_4 TERM_N_R 0.8414f
C2904 VCM_LOW_OK TERM_OR_N_B 5.2522f
C2905 TERM_GATE_P_BLEED_3 FS_P_OUT 0.04275f
C2906 TERM_TRIM1 LS_SLOW_B 0.11383f
C2907 TERM_TRIM1 HS_P_11 0.03095f
C2908 HS_P_13 TERM_GATE_P_BLEED_6 0.03489f
C2909 HS_N_7 DIV_LOW_N 0.03894f
C2910 HS_N_0 HS_P 0.10444f
C2911 PULLDOWN_P_R FS_P_CONTROL_S 0.02198f
C2912 PULLDOWN_N_R HS_N_4 0.06832f
C2913 HS_P_5 HS_P 6.77137f
C2914 TERM_TRIM0 TRIM_N_0_R 0.22416f
C2915 TERM_OR_P_S HS_N_9 0.0495f
C2916 TERM_GATE_P_BLEED_0 TERM_GATE_P_BLEED_6 0.00257f
C2917 TERM_VCM TERM_OR_P_B 0.06571f
C2918 HS_N_9 PULLUP_P_WELL 0.16859f
C2919 FS_P_WELL TERM_OR_P_B 0.06662f
C2920 HS_P_10 PULLUP_P_OUT 0.04356f
C2921 FS_P_BLEED_3 LSM_H_P 0.00219f
C2922 TERM_TRIM1 TRIM_N_1_R 0.34827f
C2923 HS_PBIAS PULLUP_N_BLEED_1 0.05271f
C2924 TERM_ENABLE HS_P_10 0.06578f
C2925 PULLUP_P_WELL FS_HIGH_P 0.44445f
C2926 PULLUP_P_BLEED_6 TERM_N_R 0.03984f
C2927 TERM_GATE_P PULLUP_N_OUT 7.05244f
C2928 TERM_GATE_N_BLEED_4 HS_N_8 0.00108f
C2929 PAD_N HS_P_5 3.96198f
C2930 PAD_N HS_N_0 1.37351f
C2931 FS_P_OUT PAD_P 0.39493f
C2932 FS_LOW_P FS_N_GATE 0.10284f
C2933 HS_N_12 PULLUP_N_OUT 0.05016f
C2934 DIV_N FS_N_GATE 0.12873f
C2935 DVDD PAD_P 61.3963f
C2936 HS_P_4 HS_P_2 0.03192f
C2937 PULLUP_P_BLEED_6 HS_N_8 0.03489f
C2938 HS_P_1 HS_P_4 0.03099f
C2939 TERM_GATE_N_BLEED_1 HS_N_4 0.03931f
C2940 HS_P_10 TERM_GATE_P 0.08707f
C2941 HS_P_2 HS_P_9 0.08047f
C2942 HS_P_3 TERM_GATE_P_BLEED_6 0.03489f
C2943 HS_P_1 HS_P_9 0.08047f
C2944 DIV_N TERM_GATE_N_BLEED_6 0.29412f
C2945 HS_PBIAS PULLUP_P_OUT 0.50308f
C2946 TERM_GATE_N_BLEED_3 HS_N_0 0.0408f
C2947 PULLUP_P HS_N_4 0.04655f
C2948 HS_PBIAS TERM_ENABLE 0.40388f
C2949 HS_P_8 TERM_GATE_N 0.0525f
C2950 TERM_GATE_P_BLEED_2 PULLUP_N_OUT 0
C2951 TERM_TRIM1 HS_P_3 0.02846f
C2952 HS_N FS_N_BLEED_6 0.05761f
C2953 TERM_TRIM1 FS_HIGH_N 0.02404f
C2954 TERM_TRIM0 HS_P 0.23018f
C2955 TERM_TRIM1 PULLUP_N_BLEED_0 0.12209f
C2956 TERM_GATE_P_BLEED_3 PULLUP_N_OUT 0.04803f
C2957 TERM_TRIM2 PULLDOWN_N_R 0.03368f
C2958 PULLUP_P_OUT HS_N_11 0.02508f
C2959 TERM_ENABLE HS_N_11 0.06335f
C2960 PULLUP_N_WELL PULLUP_N_CONTROL_S 0.09287f
C2961 PULLUP_P_GATE PULLUP_N_OUT 0.12319f
C2962 HS_P DIV_LOW_P 0.02867f
C2963 PAD_N TERM_TRIM0 1.52334f
C2964 DIV_ENABLE PULLUP_N_BLEED_1 0.03564f
C2965 DIV_LOW_N PULLDOWN_N_R 0.05264f
C2966 TERM_GATE_P_BLEED_2 HS_P_10 0.04673f
C2967 HS_PBIAS TERM_GATE_P 0.11772f
C2968 PULLUP_N_GATE TERM_TRIM1 0.34308f
C2969 PULLUP_N_OUT PAD_P 0.16918f
C2970 PULLDOWN_P_R HS_N_6 0.02921f
C2971 TERM_GATE_P_BLEED_1 HS_P_2 0
C2972 HS_PBIAS HS_N_12 9.75541f
C2973 HS_P_0 HS_N_2 0.03722f
C2974 HS_N PULLUP_N_BLEED_3 0.35035f
C2975 FS_P_OUT PULLDOWN_N_R 0
C2976 HS_P_1 TERM_GATE_P_BLEED_1 0.03311f
C2977 HS_N_9 HS_N_13 0.04877f
C2978 VDD FS_N_BLEED_0 0.00543f
C2979 TERM_GATE_N_BLEED_6 FS_N_GATE 0.00193f
C2980 PULLUP_N_BLEED_1 TERM_N_R 1.57378f
C2981 HS_N_13 FS_HIGH_P 0.05489f
C2982 TERM_GATE_P HS_N_11 0.09149f
C2983 TERM_GATE_N_BLEED_1 TERM_TRIM2 0.04294f
C2984 HS_P_4 LSNB 0.04828f
C2985 HS_P_10 HS_N_7 0.07717f
C2986 RX_N HS_N_9 0.03937f
C2987 HS_N_12 HS_N_11 99.9044f
C2988 RX_N LSM_H_P 0.06425f
C2989 HS_P_10 PAD_P 1.464f
C2990 HS_P_2 HS_N_3 0.00133f
C2991 DIV_ENABLE TERM_ENABLE 0
C2992 TERM_ENABLE TERM_OR_N_NS 0.01441f
C2993 HS_PBIAS TERM_GATE_P_BLEED_2 0.0051f
C2994 BYPASS_ENABLE PULLUP_N_WELL 0.00892f
C2995 RX_P HS_P_5 0.04185f
C2996 HS_P FS_N_BLEED_1 0.1239f
C2997 HS_P_5 HS_N_5 0.09072f
C2998 PULLUP_P_BLEED_6 TERM_GATE_N 0.05164f
C2999 TERM_TRIM1 FS_N_BLEED_4 0.01503f
C3000 PULLUP_P DIV_LOW_N 0.04739f
C3001 VDD HS_N_9 6.5231f
C3002 BYPASS_ENABLE HS_N_10 0
C3003 VDD LSM_H_P 0.57565f
C3004 PULLUP_P_BLEED_5 TERM_VCM 0.84584f
C3005 HS_P_4 TERM_OR_P_B 0.05624f
C3006 VDD FS_HIGH_P 2.99185f
C3007 HS_P_0 VCM_LOW_OK 0.06022f
C3008 TERM_LS_P_S FS_N_GATE 0
C3009 TERM_LS_N_S FS_N_GATE 0.04412f
C3010 PULLUP_P_OUT TERM_N_R 0.07654f
C3011 PULLUP_P_GATE HS_PBIAS 0.18369f
C3012 TERM_ENABLE TERM_N_R 0.07475f
C3013 HS_P_9 TERM_OR_P_B 0.07674f
C3014 RX_N TERM_GATE_P_BLEED_4 0.08699f
C3015 HS_PBIAS HS_N_7 1.78992f
C3016 DIV_ENABLE TERM_GATE_P 0.12296f
C3017 BYPASS_ENABLE FS_N_WELL 0.00766f
C3018 HS_PBIAS PAD_P 0.00127f
C3019 DIFF_ENABLE TERM_P_R 4.51212f
C3020 HS_N_3 PULLDOWN_P 0.06583f
C3021 PULLDOWN_N_R PULLUP_N_OUT 0.04319f
C3022 DIV_ENABLE HS_N_12 0.03489f
C3023 PULLUP_P_GATE HS_N_11 0.0726f
C3024 TERM_GATE_P_BLEED_1 LSNB 0.87093f
C3025 HS_P_6 HS_N_10 0.02545f
C3026 PULLUP_P_OUT HS_N_8 0.02404f
C3027 TERM_ENABLE HS_N_8 0.03587f
C3028 HS_N_7 HS_N_11 0.02542f
C3029 HS_P_11 HS_N_0 0.03489f
C3030 HS_P_5 HS_P_11 0.03165f
C3031 VDD TERM_GATE_P_BLEED_4 0.0033f
C3032 FS_LOW_P TERM_GATE_P_BLEED_6 0.10654f
C3033 HS_N_11 PAD_P 1.45711f
C3034 DIV_N TERM_GATE_P_BLEED_6 0.08541f
C3035 TERM_GATE_P TERM_N_R 0.16403f
C3036 HS_P_5 HS_P_13 0.14292f
C3037 VDD PULLUP_N 0.00534f
C3038 RX_P TERM_TRIM0 0.09177f
C3039 FS_LOW_P TERM_TRIM1 0.0651f
C3040 TERM_TRIM0 HS_N_5 0.07883f
C3041 PULLUP_P_BLEED_0 FS_N_OUT 0.03681f
C3042 HS_N_12 TERM_N_R 0.0418f
C3043 TERM_TRIM0 LS_SLOW 0.19276f
C3044 TERM_GATE_P_BLEED_0 HS_N_0 0
C3045 HS_P_10 PULLDOWN_N_R 0.07466f
C3046 PULLUP_N_BLEED_1 PULLUP_N_BLEED_4 0.00929f
C3047 LSNB HS_N_3 0.04524f
C3048 DIV_N TERM_TRIM1 0.06574f
C3049 HS_P_8 HS_P_2 0.03103f
C3050 HS_N HS_P_7 0.08791f
C3051 HS_P_1 HS_P_8 0.03089f
C3052 HS_N_2 HS_N_4 0.05055f
C3053 HS_N_5 DIV_LOW_P 0.02846f
C3054 FS_P_BLEED_4 HS_N_4 0.03931f
C3055 TERM_GATE_N_BLEED_1 PULLUP_N_OUT 0.06458f
C3056 TERM_GATE_P HS_N_8 0.08707f
C3057 HS_N_12 HS_N_8 0.00808f
C3058 FS_LOW_N HS_N_3 0.08963f
C3059 PULLUP_P PULLUP_N_OUT 18.5295f
C3060 VDD TRIM_N_2_R 0.11652f
C3061 DIV_ENABLE PULLUP_P_GATE 0
C3062 TRIM_P_0_R TERM_TRIM0 0.22416f
C3063 RX_N FS_N_CTLX 0.01826f
C3064 HS_N_9 HS_P 84.3477f
C3065 TERM_GATE_P_BLEED_2 TERM_N_R 0.0878f
C3066 DIV_ENABLE HS_N_7 0.0371f
C3067 HS_N_3 TERM_OR_P_B 0.03089f
C3068 HS_P FS_HIGH_P 0.04403f
C3069 TERM_TRIM0 TRIM_P_1_R 0
C3070 DIV_ENABLE PAD_P 0.57929f
C3071 TERM_VCM TERM_P_R 27.2633f
C3072 TERM_P_R FS_P_WELL 4.00052f
C3073 TERM_TRIM2 PULLUP_P_BLEED_4 0.00333f
C3074 FS_P_CONTROL_S FS_N_WELL 0.04908f
C3075 TERM_GATE_P_BLEED_3 TERM_N_R 0.07624f
C3076 VDD PULLUP_N_BLEED_2 0.00193f
C3077 HS_P_5 HS_P_3 0.03214f
C3078 TERM_TRIM0 HS_P_11 0.04428f
C3079 TERM_TRIM0 LS_SLOW_B 7.95766f
C3080 HS_PBIAS PULLDOWN_N_R 0.89103f
C3081 PAD_N HS_N_9 1.15014f
C3082 TERM_GATE_P_BLEED_6 FS_N_GATE 0.05573f
C3083 TERM_TRIM2 FS_N_OUT 0.29598f
C3084 VDD FS_N_CTLX 2.44178f
C3085 TERM_GATE_N_BLEED_5 TERM_P_R 0.06545f
C3086 PULLUP_P_GATE TERM_N_R 11.1574f
C3087 TERM_GATE_P_BLEED_2 HS_N_8 0.00108f
C3088 PULLUP_N_BLEED_5 TERM_P_R 0.06437f
C3089 TERM_TRIM0 TRIM_N_1_R 0
C3090 VCM_LOW_OK HS_N_4 0.02404f
C3091 TERM_TRIM1 FS_N_GATE 0.23833f
C3092 HS_P_11 DIV_LOW_P 0.06809f
C3093 PULLDOWN_P_R TERM_VCM 0.03815f
C3094 PULLDOWN_N_R HS_N_11 0.06858f
C3095 DIV_LOW_N FS_N_OUT 0.04826f
C3096 PULLDOWN_P_R FS_P_WELL 0.12006f
C3097 TERM_P_R FS_N_BLEED_2 0.01119f
C3098 TERM_N_R PAD_P 0.37001f
C3099 TERM_ENABLE LSM_L_N 0.04911f
C3100 HS_P_7 FS_P_GATE 0.05764f
C3101 FS_P_BLEED_5 FS_P_WELL 0.01613f
C3102 HS_P_13 DIV_LOW_P 0.00549f
C3103 TERM_GATE_N PULLUP_P_OUT 0.10327f
C3104 HS_P_7 HS_P_12 0
C3105 TERM_GATE_N TERM_ENABLE 0.14866f
C3106 TERM_OR_N_B HS_N_4 0.05828f
C3107 TERM_GATE_N TERM_GATE_N_BLEED_0 0.04635f
C3108 PULLUP_P_GATE HS_N_8 0.07479f
C3109 TERM_TRIM2 HS_N_2 0.04239f
C3110 TERM_GATE_N_BLEED_3 HS_N_9 0.06246f
C3111 HS_N_12 TERM_GATE_N_BLEED_2 0
C3112 FS_P_OUT FS_N_OUT 0.07278f
C3113 TERM_TRIM2 FS_P_BLEED_4 0.03302f
C3114 PULLUP_N HS_P 0.0019f
C3115 RX_N FS_N_BLEED_6 0.05428f
C3116 HS_N_8 HS_N_7 83.6861f
C3117 TERM_TRIM1 TERM_GATE_N_BLEED_6 0.01445f
C3118 BYPASS_ENABLE HS_N 0
C3119 TERM_GATE_N_BLEED_1 HS_PBIAS 0.05462f
C3120 HS_N_8 PAD_P 0.51459f
C3121 HS_N_2 DIV_LOW_N 0.03894f
C3122 HS_PBIAS PULLUP_P 0.28696f
C3123 TERM_TRIM2 FS_P_BLEED_2 0.00333f
C3124 TERM_TRIM2 LSM_H_N 0.04182f
C3125 TERM_TRIM0 HS_P_3 0.0414f
C3126 TERM_GATE_N_BLEED_1 HS_N_11 0.03931f
C3127 VDD FS_N_BLEED_6 0.41892f
C3128 TERM_TRIM0 FS_HIGH_N 0.03698f
C3129 HS_N_2 FS_P_OUT 0.04032f
C3130 HS_N_12 LSM_L_N 0.0566f
C3131 HS_N_10 HS_N_6 0.08353f
C3132 TERM_GATE_N TERM_GATE_P 0.06545f
C3133 FS_P_BLEED_4 FS_P_OUT 0.05497f
C3134 TERM_TRIM0 PULLUP_N_BLEED_0 0.02402f
C3135 TERM_GATE_N_BLEED_4 PULLDOWN_P 0.26852f
C3136 HS_P_8 TERM_OR_P_B 0.05493f
C3137 PULLUP_P HS_N_11 0.04655f
C3138 HS_N HS_P_6 0.21259f
C3139 TERM_OR_N_NS PULLDOWN_N_R 0.00267f
C3140 TERM_GATE_N HS_N_12 0.02482f
C3141 TERM_TRIM1 TERM_LS_P_S 0.05428f
C3142 HS_P_3 DIV_LOW_P 0.00291f
C3143 PULLUP_P_BLEED_2 PULLUP_P_BLEED_6 0.00257f
C3144 TERM_TRIM2 VCM_LOW_OK 0.04157f
C3145 PAD_N TRIM_N_2_R 1.0633f
C3146 PULLUP_P_BLEED_6 PULLDOWN_P 0.00104f
C3147 PULLUP_N_GATE TERM_TRIM0 0.21918f
C3148 HS_P FS_N_CTLX 0
C3149 TERM_TRIM2 TERM_OR_N_B 0.02846f
C3150 PULLDOWN_N_R TERM_N_R 0.04208f
C3151 BYPASS_ENABLE FS_P_GATE 0.07816f
C3152 RX_P HS_N_9 0.04185f
C3153 VCM_LOW_OK FS_P_OUT 0.09125f
C3154 HS_N_5 HS_N_9 0.04325f
C3155 TERM_GATE_N_BLEED_1 DIV_ENABLE 0.01424f
C3156 RX_P LSM_H_P 0.04849f
C3157 TERM_GATE_N TERM_GATE_P_BLEED_3 0.03449f
C3158 LSM_L_P FS_P_GATE 0.04329f
C3159 PULLUP_P_BLEED_6 LSNB 0.04828f
C3160 HS_N_5 FS_HIGH_P 0.04403f
C3161 HS_N_8 PULLDOWN_N_R 0.02404f
C3162 LS_SLOW LSM_H_P 2.71921f
C3163 PULLUP_P TERM_OR_N_NS 0.66296f
C3164 PULLUP_P_OUT FS_P_CTLX 0.01489f
C3165 FS_P_BLEED_0 FS_P_GATE 0.52614f
C3166 PULLUP_P_GATE TERM_GATE_N 0.08664f
C3167 BYPASS_ENABLE TERM_OR_N_S 0.00444f
C3168 HS_P_6 HS_N_1 0.02599f
C3169 TERM_GATE_P_BLEED_5 TERM_GATE_P 0.00219f
C3170 TERM_ENABLE FS_P_CTLX 0.02564f
C3171 FS_LOW_P HS_P_5 0.04566f
C3172 HS_N_2 PULLUP_N_OUT 0.0044f
C3173 FS_LOW_P HS_N_0 0.04607f
C3174 TERM_GATE_N HS_N_7 0.02404f
C3175 HS_P_4 TERM_P_R 0.04412f
C3176 FS_P_BLEED_4 PULLUP_N_OUT 0.25436f
C3177 TERM_TRIM0 FS_N_BLEED_4 0.03838f
C3178 PULLUP_P_BLEED_6 FS_LOW_N 0.03508f
C3179 DIV_N HS_N_0 0.04536f
C3180 TERM_GATE_N PAD_P 0.22596f
C3181 HS_P_6 HS_P_12 0.08462f
C3182 TERM_GATE_N_BLEED_1 TERM_N_R 1.57378f
C3183 HS_P_9 TERM_P_R 0.03089f
C3184 FS_N_BLEED_6 HS_P 0.04828f
C3185 PULLUP_P TERM_N_R 0.11547f
C3186 BYPASS_ENABLE PULLUP_P_WELL 0.01658f
C3187 RX_P TERM_GATE_P_BLEED_4 0.05373f
C3188 LSM_H_N PULLUP_N_OUT 0.2991f
C3189 PULLDOWN_P_R HS_P_4 0.02482f
C3190 LS_SLOW TERM_GATE_P_BLEED_4 0.12973f
C3191 HS_P_11 HS_N_9 0.06578f
C3192 HS_P_10 HS_N_2 0.03089f
C3193 LSM_H_P LS_SLOW_B 1.43199f
C3194 TERM_GATE_N_BLEED_1 HS_N_8 0.03931f
C3195 LSM_L_P FS_P_BLEED_3 0.05022f
C3196 HS_P_11 FS_HIGH_P 0.10312f
C3197 PULLDOWN_P_R HS_P_9 0.06825f
C3198 HS_P_13 HS_N_9 0.03117f
C3199 TERM_TRIM1 TERM_GATE_P_BLEED_6 0.04133f
C3200 PULLUP_P_OUT HS_P_2 0.04113f
C3201 FS_P_CONTROL_S FS_P_GATE 1.07582f
C3202 HS_PBIAS FS_N_OUT 0.76132f
C3203 TERM_ENABLE HS_P_2 0.06335f
C3204 HS_P_13 FS_HIGH_P 0.08264f
C3205 HS_P_1 PULLUP_P_OUT 0.04891f
C3206 HS_P_0 HS_N_4 0.03487f
C3207 VCM_LOW_OK PULLUP_N_OUT 3.43073f
C3208 PULLUP_N_BLEED_1 PULLDOWN_P 0.04618f
C3209 HS_P_1 TERM_ENABLE 0.04571f
C3210 PULLDOWN_N_R PULLUP_N_BLEED_4 0.09682f
C3211 PULLUP_N_BLEED_3 HS_P 0.1239f
C3212 FS_HIGH_N FS_N_BLEED_0 0.00961f
C3213 FS_LOW_P TERM_TRIM0 0.04695f
C3214 TERM_OR_N_B PULLUP_N_OUT 0.05613f
C3215 HS_P_5 FS_N_GATE 0.04032f
C3216 BYPASS_ENABLE DIV_P 0.06279f
C3217 HS_N_11 FS_N_OUT 0
C3218 DIV_N TERM_TRIM0 0.09569f
C3219 TERM_GATE_P_BLEED_4 LS_SLOW_B 0.23676f
C3220 HS_PBIAS HS_N_2 2.6154f
C3221 HS_N HS_N_6 2.3684f
C3222 VDD HS_P_7 5.10774f
C3223 PULLDOWN_N_R LSM_L_N 0.00267f
C3224 HS_PBIAS FS_P_BLEED_4 0.05271f
C3225 VCM_LOW_OK HS_P_10 0.11804f
C3226 HS_P_2 TERM_GATE_P 0.03931f
C3227 TERM_GATE_N PULLDOWN_N_R 0.07486f
C3228 HS_P_1 TERM_GATE_P 0.09149f
C3229 HS_N_3 TERM_P_R 0.0414f
C3230 TERM_VCM PULLUP_N_WELL 0.2262f
C3231 HS_P_3 HS_N_9 0.03089f
C3232 RX_P FS_N_CTLX 0
C3233 HS_N_12 HS_P_2 0.03425f
C3234 TERM_GATE_N_BLEED_1 TERM_GATE_N_BLEED_2 0.96553f
C3235 TERM_ENABLE PULLDOWN_P 0.03394f
C3236 HS_N_2 HS_N_11 0.00106f
C3237 LS_SLOW FS_N_CTLX 0
C3238 VDD PULLUP_N_CONTROL_S 0.43813f
C3239 FS_P_BLEED_4 HS_N_11 0.03931f
C3240 HS_PBIAS LSM_H_N 0.13081f
C3241 FS_HIGH_N FS_HIGH_P 91.3594f
C3242 FS_LOW_N PULLUP_N_BLEED_1 0.07126f
C3243 HS_N_10 FS_P_WELL 0.16381f
C3244 PULLDOWN_P_R HS_N_3 0.02846f
C3245 DIV_ENABLE FS_N_OUT 0.12482f
C3246 PULLUP_P_OUT LSNB 0.06369f
C3247 PULLUP_P_BLEED_1 HS_N_10 0.04007f
C3248 TERM_VCM FS_N_WELL 4.01839f
C3249 TERM_GATE_P_BLEED_2 HS_P_2 0.03224f
C3250 HS_PBIAS VCM_LOW_OK 0.39832f
C3251 TRIM_N_2_R TRIM_N_1_R 0.05735f
C3252 HS_P_1 TERM_GATE_P_BLEED_2 0.07129f
C3253 FS_P_BLEED_6 HS_N_6 0.04781f
C3254 TERM_ENABLE LSNB 0.07634f
C3255 FS_P_WELL FS_N_WELL 0.11672f
C3256 TERM_TRIM0 FS_N_GATE 0.25153f
C3257 TERM_GATE_N_BLEED_1 TERM_GATE_N 0.58712f
C3258 BYPASS_ENABLE RX_N 3.23861f
C3259 PULLUP_N_GATE FS_HIGH_P 0.03618f
C3260 PULLUP_P LSM_L_N 0.04364f
C3261 HS_N_1 HS_N_6 0.07157f
C3262 FS_P_GATE HS_N_6 0.07464f
C3263 HS_N_12 PULLDOWN_P 0.06603f
C3264 TERM_GATE_N_BLEED_5 FS_N_WELL 0.0899f
C3265 PULLUP_P TERM_GATE_N 7.85961f
C3266 HS_PBIAS TERM_OR_N_B 0.12484f
C3267 LS_SLOW_B FS_N_CTLX 0.25822f
C3268 VCM_LOW_OK HS_N_11 0.02404f
C3269 HS_P_12 HS_N_6 0.02404f
C3270 PULLDOWN_N DIFF_ENABLE 0.12304f
C3271 RX_P FS_N_BLEED_6 0.04337f
C3272 TERM_N_R FS_N_OUT 0.06202f
C3273 DIV_ENABLE HS_N_2 0.03489f
C3274 TERM_ENABLE FS_LOW_N 0.04966f
C3275 DIV_ENABLE FS_P_BLEED_4 0.01375f
C3276 HS_P_6 HS_N_13 0.02464f
C3277 FS_N_WELL FS_N_BLEED_2 0
C3278 LS_SLOW FS_N_BLEED_6 0.05482f
C3279 HS_P_2 HS_N_7 0.00376f
C3280 TERM_TRIM0 TERM_GATE_N_BLEED_6 0.048f
C3281 PULLUP_P_OUT TERM_OR_P_B 0.14502f
C3282 BYPASS_ENABLE VDD 0.04691f
C3283 HS_P_1 HS_N_7 0.05874f
C3284 HS_P_2 PAD_P 1.71344f
C3285 TERM_ENABLE TERM_OR_P_B 0.45628f
C3286 TERM_OR_N_B HS_N_11 0.05851f
C3287 PULLUP_P_BLEED_5 PULLUP_P_BLEED_6 1.41012f
C3288 HS_P_1 PAD_P 1.45976f
C3289 TERM_GATE_P LSNB 0.05271f
C3290 HS_P_7 HS_P 1.42957f
C3291 TERM_OR_N_S HS_N_6 0.02404f
C3292 HS_N_12 LSNB 0.04686f
C3293 VDD LSM_L_P 14.0445f
C3294 HS_P_8 TERM_P_R 0.06878f
C3295 HS_N DIFF_ENABLE 0.24066f
C3296 PULLUP_N_WELL FS_N_BLEED_5 0
C3297 HS_N_2 TERM_N_R 0.08666f
C3298 PULLUP_N_GATE PULLUP_N 1.51297f
C3299 FS_P_BLEED_4 TERM_N_R 0.03984f
C3300 VDD FS_P_BLEED_0 0.04843f
C3301 PAD_N HS_P_7 1.04299f
C3302 PULLUP_P_BLEED_2 PULLUP_P_GATE 0.14196f
C3303 PULLUP_N_CONTROL_S HS_P 0.03228f
C3304 TERM_OR_P_S HS_N_6 0.04472f
C3305 VDD HS_P_6 4.87418f
C3306 FS_LOW_N HS_N_12 0.08963f
C3307 TERM_TRIM0 TERM_LS_P_S 1.33458f
C3308 PULLUP_P_BLEED_2 HS_N_7 0
C3309 PULLUP_P_WELL HS_N_6 0.15592f
C3310 FS_LOW_P FS_N_BLEED_0 0.13743f
C3311 PULLUP_P_GATE PULLDOWN_P 0.00156f
C3312 TERM_GATE_P TERM_OR_P_B 3.03475f
C3313 FS_N_BLEED_6 LS_SLOW_B 0.06713f
C3314 FS_HIGH_N PULLUP_N_BLEED_2 0.00933f
C3315 DIV_ENABLE VCM_LOW_OK 0
C3316 PULLDOWN_P_R HS_P_8 0.0676f
C3317 FS_N_GATE FS_N_BLEED_1 0
C3318 FS_N_BLEED_3 FS_N_BLEED_2 0.06051f
C3319 HS_N_2 HS_N_8 0.04062f
C3320 VCM_LOW_OK TERM_OR_N_NS 1.10103f
C3321 HS_N_7 PULLDOWN_P 0.02404f
C3322 LSM_H_N TERM_N_R 0.07795f
C3323 HS_N_12 TERM_OR_P_B 0.03208f
C3324 FS_P_BLEED_4 HS_N_8 0.03931f
C3325 FS_HIGH_N FS_N_CTLX 0.16424f
C3326 RX_N FS_P_CONTROL_S 0.03722f
C3327 TERM_OR_N_NS TERM_OR_N_B 0.60128f
C3328 HS_P_0 PULLUP_N_OUT 0.00322f
C3329 TERM_VCM PULLDOWN_N 0.0428f
C3330 VCM_LOW_OK TERM_N_R 0.09764f
C3331 PULLUP_P_GATE LSNB 0.09646f
C3332 PULLUP_N_GATE PULLUP_N_BLEED_2 0
C3333 FS_LOW_P HS_N_9 0.04574f
C3334 TERM_GATE_N_BLEED_2 FS_N_OUT 0.0363f
C3335 TERM_GATE_P_BLEED_6 HS_N_0 0.03489f
C3336 TERM_TRIM2 HS_N_4 0.07775f
C3337 HS_P_5 TERM_GATE_P_BLEED_6 0.03489f
C3338 LSNB HS_N_7 0.053f
C3339 VDD FS_P_CONTROL_S 1.45864f
C3340 TERM_GATE_N_BLEED_4 TERM_P_R 0.01119f
C3341 FS_LOW_P FS_HIGH_P 9.70014f
C3342 PULLUP_P_BLEED_6 PULLUP_P_BLEED_3 0.1071f
C3343 DIV_N HS_N_9 0.04536f
C3344 PULLDOWN_N PULLUP_N_BLEED_5 0.0078f
C3345 DIV_P HS_N_6 0.03388f
C3346 HS_P_2 PULLDOWN_N_R 0.07217f
C3347 HS_P_1 PULLDOWN_N_R 0.07217f
C3348 TERM_TRIM1 HS_P_5 0.03095f
C3349 TERM_N_R TERM_OR_N_B 5.86894f
C3350 DIV_N FS_HIGH_P 8.68122f
C3351 BYPASS_ENABLE HS_P 0
C3352 HS_P_4 HS_N_10 0.03489f
C3353 PULLUP_P_GATE FS_LOW_N 0.00818f
C3354 DIV_LOW_N HS_N_4 0.03894f
C3355 VCM_LOW_OK HS_N_8 0.02534f
C3356 HS_N FS_P_WELL 24.7932f
C3357 HS_P_0 HS_P_10 2.2239f
C3358 FS_LOW_N HS_N_7 0.08963f
C3359 TERM_TRIM2 TRIM_P_2_R 0.59166f
C3360 PULLUP_P_BLEED_6 TERM_P_R 0.04034f
C3361 PULLUP_N_BLEED_6 PULLDOWN_N 0.00832f
C3362 HS_P_9 HS_N_10 0.03425f
C3363 TERM_VCM PULLUP_P_CONTROL_S 0.05405f
C3364 FS_N_GATE FS_N_BLEED_0 0
C3365 FS_N_BLEED_6 FS_HIGH_N 0.1661f
C3366 BYPASS_ENABLE PAD_N 2.43825f
C3367 HS_N_7 TERM_OR_P_B 0.03089f
C3368 HS_N_8 TERM_OR_N_B 0.0595f
C3369 HS_N PULLUP_P_BLEED_1 0.33695f
C3370 TERM_GATE_N FS_N_OUT 0.10099f
C3371 HS_P_4 FS_N_WELL 0.0628f
C3372 FS_P_BLEED_0 HS_P 0.00212f
C3373 PULLUP_P_BLEED_2 PULLDOWN_N_R 0.06464f
C3374 HS_P_6 HS_P 1.8055f
C3375 PULLDOWN_P_R PULLUP_P_BLEED_6 0.04806f
C3376 HS_P_9 FS_N_WELL 0.04908f
C3377 PULLDOWN_N_R PULLDOWN_P 51.4867f
C3378 HS_N_6 HS_N_13 0.25734f
C3379 PULLUP_N_GATE FS_N_BLEED_6 0.00475f
C3380 TERM_TRIM0 TERM_GATE_P_BLEED_6 0.05601f
C3381 HS_P_0 HS_PBIAS 20.4886f
C3382 HS_N_9 FS_N_GATE 0.04032f
C3383 PAD_N HS_P_6 0.99768f
C3384 TERM_GATE_N HS_N_2 0.05297f
C3385 LSM_H_P FS_N_GATE 0.03709f
C3386 FS_P_BLEED_4 TERM_GATE_N 0.04557f
C3387 FS_P_BLEED_6 FS_P_WELL 0.14887f
C3388 FS_N_GATE FS_HIGH_P 0.01347f
C3389 TERM_TRIM1 TERM_TRIM0 0.22106p
C3390 HS_N_1 FS_P_WELL 0.17326f
C3391 TERM_GATE_P_BLEED_1 HS_N_10 0.04001f
C3392 TERM_VCM FS_P_GATE 1.56132f
C3393 TERM_GATE_P_BLEED_6 DIV_LOW_P 0
C3394 FS_P_GATE FS_P_WELL 44.2371f
C3395 LSM_H_N LSM_L_N 0.06816f
C3396 TERM_VCM HS_P_12 0.02427f
C3397 TERM_TRIM2 DIV_LOW_N 0.03302f
C3398 HS_P_0 HS_N_11 0.0525f
C3399 LSNB PULLDOWN_N_R 0.11859f
C3400 HS_P_12 FS_P_WELL 0.18943f
C3401 PULLUP_P_BLEED_1 HS_N_1 0.04034f
C3402 VDD HS_N_6 4.66908f
C3403 TERM_GATE_N_BLEED_1 PULLDOWN_P 0.38298f
C3404 TERM_TRIM2 FS_P_OUT 0.03245f
C3405 PULLUP_P_BLEED_2 PULLUP_P 0
C3406 FS_LOW_P PULLUP_N_BLEED_2 0.05872f
C3407 PULLUP_N_GATE PULLUP_N_BLEED_3 0
C3408 HS_N_4 PULLUP_N_OUT 0.05016f
C3409 HS_N_3 HS_N_10 0.03047f
C3410 TERM_VCM TERM_OR_N_S 0.09283f
C3411 FS_LOW_N PULLDOWN_N_R 0.11184f
C3412 FS_N_BLEED_6 FS_N_BLEED_4 0.23498f
C3413 TERM_GATE_P_BLEED_4 FS_N_GATE 0.00183f
C3414 HS_P_7 HS_P_11 0
C3415 TERM_GATE_N VCM_LOW_OK 0.08399f
C3416 PULLDOWN_N_R TERM_OR_P_B 0.091f
C3417 PULLUP_N_BLEED_1 TERM_P_R 0.05846f
C3418 HS_N_3 FS_N_WELL 0.05647f
C3419 TERM_TRIM1 VSS 15.6029f
C3420 TERM_TRIM2 VSS 17.7505f
C3421 RX_P VSS 37.2443f
C3422 RX_N VSS 50.005f
C3423 BYPASS_ENABLE VSS 46.5318f
C3424 HS_N VSS 60.7207f
C3425 PAD_N VSS 0.42485p
C3426 PAD_P VSS 0.40701p
C3427 HS_P VSS 45.9655f
C3428 TERM_VCM VSS 0.90727p
C3429 FS_HIGH_P VSS 8.25669f
C3430 PULLDOWN_P VSS 10.441f
C3431 TERM_TRIM0 VSS 40.1422f
C3432 DIV_ENABLE VSS 23.6518f
C3433 FS_HIGH_N VSS 11.9268f
C3434 HS_PBIAS VSS 59.0387f
C3435 TERM_ENABLE VSS 16.4075f
C3436 FS_LOW_P VSS 34.3023f
C3437 LS_SLOW VSS 41.9118f
C3438 PULLDOWN_N VSS 16.4709f
C3439 PULLUP_P VSS 27.8522f
C3440 DIFF_ENABLE VSS 15.2885f
C3441 FS_LOW_N VSS 11.4789f
C3442 PULLUP_N VSS 12.9574f
C3443 DVDD VSS 0.29085p
C3444 VDD VSS 0.76449p
C3445 TRIM_N_0_R VSS 3.01798f
C3446 TRIM_N_1_R VSS 5.25228f
C3447 TRIM_N_2_R VSS 9.97495f
C3448 TRIM_P_0_R VSS 3.01798f
C3449 TRIM_P_1_R VSS 5.25228f
C3450 TRIM_P_2_R VSS 9.97495f
C3451 TERM_OR_P_NS VSS 4.9665f
C3452 TERM_LS_P_S VSS 2.80111f
C3453 TERM_OR_P_B VSS 7.74444f
C3454 TERM_OR_P_S VSS 2.79264f
C3455 TERM_GATE_P_BLEED_5 VSS 3.47879f
C3456 TERM_GATE_P_BLEED_4 VSS 3.5679f
C3457 TERM_GATE_P_BLEED_3 VSS 3.64516f
C3458 TERM_GATE_P_BLEED_2 VSS 4.91587f
C3459 TERM_GATE_P_BLEED_1 VSS 3.72176f
C3460 TERM_GATE_P_BLEED_0 VSS 3.91524f
C3461 TERM_GATE_P VSS 33.2575f
C3462 HS_P_3 VSS 6.24849f
C3463 HS_P_2 VSS 6.43968f
C3464 HS_P_1 VSS 6.37131f
C3465 HS_P_0 VSS 7.12565f
C3466 DIV_LOW_P VSS 5.98133f
C3467 DIV_P VSS 14.2972f
C3468 TERM_GATE_P_BLEED_6 VSS 13.5252f
C3469 HS_P_10 VSS 7.97691f
C3470 HS_P_9 VSS 6.88927f
C3471 HS_P_8 VSS 6.21528f
C3472 HS_P_7 VSS 5.0902f
C3473 HS_P_6 VSS 6.76295f
C3474 HS_P_5 VSS 6.79657f
C3475 HS_P_4 VSS 7.43951f
C3476 FS_P_CTLX VSS 8.09377f
C3477 FS_P_CONTROL_S VSS 11.0978f
C3478 HS_P_13 VSS 7.1275f
C3479 HS_P_12 VSS 6.89148f
C3480 HS_P_11 VSS 8.56411f
C3481 FS_P_BLEED_3 VSS 3.546f
C3482 FS_P_BLEED_2 VSS 3.54436f
C3483 FS_P_BLEED_1 VSS 3.62462f
C3484 FS_P_BLEED_0 VSS 4.28972f
C3485 LSM_L_P VSS 13.1247f
C3486 FS_P_OUT VSS 15.5668f
C3487 LSM_H_P VSS 14.9283f
C3488 FS_P_GATE VSS 25.0739f
C3489 FS_P_BLEED_6 VSS 3.72018f
C3490 FS_P_BLEED_5 VSS 3.91368f
C3491 FS_P_BLEED_4 VSS 11.123f
C3492 PULLUP_P_CONTROL_S VSS 4.10844f
C3493 PULLUP_P_OUT VSS 4.76311f
C3494 PULLUP_P_BLEED_5 VSS 3.48167f
C3495 PULLUP_P_BLEED_4 VSS 3.56866f
C3496 PULLUP_P_BLEED_3 VSS 3.45636f
C3497 PULLUP_P_BLEED_2 VSS 4.92298f
C3498 PULLUP_P_BLEED_1 VSS 3.47001f
C3499 PULLUP_P_BLEED_0 VSS 3.91075f
C3500 TERM_OR_N_NS VSS 4.65688f
C3501 PULLDOWN_P_R VSS 9.48935f
C3502 PULLUP_P_GATE VSS 12.0208f
C3503 PULLUP_P_BLEED_6 VSS 9.31749f
C3504 TERM_GATE_N_BLEED_0 VSS 3.20612f
C3505 TERM_LS_N_S VSS 1.36104f
C3506 TERM_GATE_N VSS 28.9868f
C3507 TERM_OR_N_B VSS 12.2303f
C3508 TERM_OR_N_S VSS 6.03246f
C3509 VCM_LOW_OK VSS 14.9302f
C3510 DIV_N VSS 22.6422f
C3511 TERM_GATE_N_BLEED_6 VSS 3.57908f
C3512 TERM_GATE_N_BLEED_5 VSS 3.57636f
C3513 TERM_GATE_N_BLEED_4 VSS 4.22571f
C3514 TERM_GATE_N_BLEED_3 VSS 3.4716f
C3515 TERM_GATE_N_BLEED_2 VSS 3.9137f
C3516 TERM_GATE_N_BLEED_1 VSS 11.1449f
C3517 HS_N_5 VSS 9.76205f
C3518 HS_N_4 VSS 8.06736f
C3519 HS_N_3 VSS 7.06361f
C3520 HS_N_2 VSS 8.76736f
C3521 HS_N_1 VSS 8.36772f
C3522 HS_N_0 VSS 7.48898f
C3523 DIV_LOW_N VSS 11.0109f
C3524 HS_N_12 VSS 9.47914f
C3525 HS_N_11 VSS 9.63036f
C3526 HS_N_10 VSS 9.12195f
C3527 HS_N_9 VSS 8.23258f
C3528 HS_N_8 VSS 7.46007f
C3529 HS_N_7 VSS 6.42593f
C3530 HS_N_6 VSS 8.27195f
C3531 LSNB VSS 25.0786f
C3532 FS_N_CTLX VSS 7.63319f
C3533 FS_N_CONTROL_S VSS 10.7651f
C3534 HS_N_13 VSS 9.25695f
C3535 FS_N_BLEED_5 VSS 3.47886f
C3536 FS_N_BLEED_4 VSS 3.53784f
C3537 FS_N_BLEED_3 VSS 3.59952f
C3538 FS_N_BLEED_2 VSS 4.2348f
C3539 FS_N_BLEED_1 VSS 3.47262f
C3540 FS_N_BLEED_0 VSS 3.8654f
C3541 LSM_L_N VSS 15.7638f
C3542 LS_SLOW_B VSS 34.3279f
C3543 FS_N_OUT VSS 27.6746f
C3544 LSM_H_N VSS 17.0312f
C3545 FS_N_GATE VSS 43.7401f
C3546 FS_N_BLEED_6 VSS 8.23784f
C3547 PULLUP_N_BLEED_0 VSS 3.31538f
C3548 PULLUP_N_CONTROL_S VSS 3.79819f
C3549 PULLUP_N_OUT VSS 13.4778f
C3550 PULLDOWN_N_R VSS 24.3441f
C3551 PULLUP_N_GATE VSS 10.7026f
C3552 PULLUP_N_BLEED_6 VSS 3.56366f
C3553 PULLUP_N_BLEED_5 VSS 3.65848f
C3554 PULLUP_N_BLEED_4 VSS 4.20567f
C3555 PULLUP_N_BLEED_3 VSS 3.57508f
C3556 PULLUP_N_BLEED_2 VSS 3.91058f
C3557 PULLUP_N_BLEED_1 VSS 11.0501f
C3558 TERM_P_R VSS 47.6586f
C3559 TERM_N_R VSS 48.8282f
C3560 FS_P_WELL VSS 0.15729p
C3561 PULLUP_P_WELL VSS 69.44939f
C3562 FS_N_WELL VSS 0.17102p
C3563 PULLUP_N_WELL VSS 63.7525f
.ends

.lib /home/ubuntu/svalbard/scratch/transceiver-pad-pdk/ngspice/sm141064.ngspice diode_typical
.lib /home/ubuntu/svalbard/scratch/transceiver-pad-pdk/ngspice/sm141064.ngspice mimcap_typical
