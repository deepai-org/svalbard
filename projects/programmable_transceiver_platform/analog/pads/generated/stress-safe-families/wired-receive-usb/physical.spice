.subckt tx_protected_pad PAD_P PAD_N VDD VSS TERM_VCM TERM_ENABLE DIFF_ENABLE DIV_ENABLE BYPASS_ENABLE RX_P RX_N HS_PBIAS HS_P HS_N FS_HIGH_P FS_HIGH_N FS_LOW_P FS_LOW_N PULLUP_P PULLUP_N PULLDOWN_P PULLDOWN_N TERM_TRIM0 TERM_TRIM1 TERM_TRIM2 LS_SLOW ATB_ESD_RAIL
XPHYSICAL PAD_P PAD_N VDD VSS TERM_VCM TERM_ENABLE DIFF_ENABLE DIV_ENABLE BYPASS_ENABLE RX_P RX_N HS_PBIAS HS_P HS_N FS_HIGH_P FS_HIGH_N FS_LOW_P FS_LOW_N PULLUP_P PULLUP_N PULLDOWN_P PULLDOWN_N TERM_TRIM0 TERM_TRIM1 TERM_TRIM2 LS_SLOW ESD_RAIL ATB_ESD_RAIL combined_flat
.ends tx_protected_pad
* NGSPICE file created from combined_flat.ext - technology: gf180mcuD

.subckt combined_flat PAD_P PAD_N VDD VSS TERM_VCM TERM_ENABLE DIFF_ENABLE DIV_ENABLE
+ BYPASS_ENABLE RX_P RX_N HS_PBIAS HS_P HS_N FS_HIGH_P FS_HIGH_N FS_LOW_P FS_LOW_N
+ PULLUP_P PULLUP_N PULLDOWN_P PULLDOWN_N TERM_TRIM0 TERM_TRIM1 TERM_TRIM2 LS_SLOW
+ ESD_RAIL ATB_ESD_RAIL
X0 FS_N_OUT FS_N_GATE FS_N_WELL FS_N_WELL pfet_03v3 ad=6.16p pd=28.88u as=6.16p ps=28.88u w=14u l=0.28u
X1 TERM_P_R TERM_GATE_P TERM_VCM VSS nfet_06v0 ad=8.8p pd=40.88u as=8.8p ps=40.88u w=20u l=0.7u
X2 VSS a_42245_90628# ESD_RAIL VSS nfet_06v0 ad=13p pd=50.52u as=13p ps=50.52u w=50u l=0.7u
X3 VSS a_41852_148519# ESD_RAIL VSS nfet_06v0 ad=13.936p pd=54.12u as=13.936p ps=54.12u w=53.6u l=0.7u
X4 ESD_RAIL a_41852_148519# VSS VSS nfet_06v0 ad=13.936p pd=54.12u as=13.936p ps=54.12u w=53.6u l=0.7u
X5 a_42245_90628# a_44789_117064# VSS VSS nfet_06v0 ad=1.3p pd=5.52u as=1.3p ps=5.52u w=5u l=0.7u
X6 ESD_RAIL a_44789_117064# a_42245_90628# ESD_RAIL pfet_06v0 ad=1.3p pd=5.52u as=1.3p ps=5.52u w=5u l=0.7u
X7 VSS a_41852_148519# ESD_RAIL VSS nfet_06v0 ad=13.936p pd=54.12u as=13.936p ps=54.12u w=53.6u l=0.7u
X8 ESD_RAIL a_42245_90628# VSS VSS nfet_06v0 ad=13p pd=50.52u as=13p ps=50.52u w=50u l=0.7u
X9 TERM_GATE_P_BLEED_0 TERM_GATE_P_BLEED_1 VSS ppolyf_u_1k r_width=1u r_length=12.5u
X10 a_42245_90628# a_44789_117064# ESD_RAIL ESD_RAIL pfet_06v0 ad=1.3p pd=5.52u as=1.3p ps=5.52u w=5u l=0.7u
X11 PULLUP_N_BLEED_3 PULLUP_N_BLEED_4 VSS ppolyf_u_1k r_width=1u r_length=12.5u
D0 VSS PULLUP_P diode_nd2ps_03v3 pj=6.96u area=3.0276p
X12 ESD_RAIL a_41005_131545# a_43813_117064# ESD_RAIL pfet_06v0 ad=1.3p pd=5.52u as=1.3p ps=5.52u w=5u l=0.7u
X13 HS_N_5 HS_N PAD_N VSS nfet_06v0 ad=8.8p pd=40.88u as=8.8p ps=40.88u w=20u l=0.7u
X14 VDD PULLUP_N_GATE PULLUP_N_WELL PULLUP_N_WELL pfet_06v0 ad=8.8p pd=40.88u as=8.8p ps=40.88u w=20u l=0.55u
X15 ESD_RAIL a_41852_148519# VSS VSS nfet_06v0 ad=13.936p pd=54.12u as=13.936p ps=54.12u w=53.6u l=0.7u
X16 VSS a_41852_148519# ESD_RAIL VSS nfet_06v0 ad=13.936p pd=54.12u as=13.936p ps=54.12u w=53.6u l=0.7u
D1 PAD_N ESD_RAIL diode_pd2nw_06v0 pj=51.8u area=22.5p
X17 ESD_RAIL ATB_ESD_RAIL VSS ppolyf_u_1k_6p0 r_width=1u r_length=0.47474m
X18 DIV_LOW_N DIV_ENABLE VSS VSS nfet_06v0 ad=8.8p pd=40.88u as=8.8p ps=40.88u w=20u l=0.7u
X19 HS_P_0 HS_PBIAS VDD VDD pfet_03v3 ad=8.8p pd=40.88u as=8.8p ps=40.88u w=20u l=1u
X20 ESD_RAIL a_41852_148519# VSS VSS nfet_06v0 ad=13.936p pd=54.12u as=13.936p ps=54.12u w=53.6u l=0.7u
X21 ESD_RAIL a_42245_90628# VSS VSS nfet_06v0 ad=13p pd=50.52u as=13p ps=50.52u w=50u l=0.7u
X22 a_42245_90628# a_44789_117064# ESD_RAIL ESD_RAIL pfet_06v0 ad=1.3p pd=5.52u as=1.3p ps=5.52u w=5u l=0.7u
X23 ESD_RAIL a_41852_148519# VSS VSS nfet_06v0 ad=13.936p pd=54.12u as=13.936p ps=54.12u w=53.6u l=0.7u
X24 TERM_N_R TERM_LSA_GATE_N TERM_VCM VSS nfet_06v0 ad=8.8p pd=40.88u as=8.8p ps=40.88u w=20u l=0.7u
X25 FS_P_OUT FS_PB_GATE FS_P_WELL FS_P_WELL pfet_03v3 ad=6.16p pd=28.88u as=6.16p ps=28.88u w=14u l=0.28u
X26 FS_N_OUT FS_NB_GATE FS_N_WELL FS_N_WELL pfet_03v3 ad=6.16p pd=28.88u as=6.16p ps=28.88u w=14u l=0.28u
X27 HS_N_5 HS_PBIAS VDD VDD pfet_03v3 ad=8.8p pd=40.88u as=8.8p ps=40.88u w=20u l=1u
X28 VSS a_41852_148519# ESD_RAIL VSS nfet_06v0 ad=13.936p pd=54.12u as=13.936p ps=54.12u w=53.6u l=0.7u
X29 VSS a_41852_148519# ESD_RAIL VSS nfet_06v0 ad=13.936p pd=54.12u as=13.936p ps=54.12u w=53.6u l=0.7u
X30 FS_N_OUT FS_NB_GATE FS_N_WELL FS_N_WELL pfet_03v3 ad=6.16p pd=28.88u as=6.16p ps=28.88u w=14u l=0.28u
X31 TERM_N_R TERM_GATE_N TERM_VCM VSS nfet_06v0 ad=8.8p pd=40.88u as=8.8p ps=40.88u w=20u l=0.7u
X32 VSS a_41852_148519# ESD_RAIL VSS nfet_06v0 ad=13.936p pd=54.12u as=13.936p ps=54.12u w=53.6u l=0.7u
X33 TERM_P_R TERM_GATE_P TERM_VCM VSS nfet_06v0 ad=8.8p pd=40.88u as=8.8p ps=40.88u w=20u l=0.7u
X34 ESD_RAIL a_42245_90628# VSS VSS nfet_06v0 ad=13p pd=50.52u as=13p ps=50.52u w=50u l=0.7u
X35 HS_N_4 HS_N PAD_N VSS nfet_06v0 ad=8.8p pd=40.88u as=8.8p ps=40.88u w=20u l=0.7u
X36 ESD_RAIL a_42245_90628# VSS VSS nfet_06v0 ad=13p pd=50.52u as=13p ps=50.52u w=50u l=0.7u
X37 VDD PULLUP_N_GATE PULLUP_N_WELL PULLUP_N_WELL pfet_06v0 ad=8.8p pd=40.88u as=8.8p ps=40.88u w=20u l=0.55u
X38 FS_N_OUT FS_N_GATE FS_N_WELL FS_N_WELL pfet_03v3 ad=6.16p pd=28.88u as=6.16p ps=28.88u w=14u l=0.28u
X39 FS_P_OUT FS_PB_GATE FS_P_WELL FS_P_WELL pfet_03v3 ad=6.16p pd=28.88u as=6.16p ps=28.88u w=14u l=0.28u
D2 PAD_N ESD_RAIL diode_pd2nw_06v0 pj=51.8u area=22.5p
X40 TRIM_N_2_R TERM_TRIM2 TERM_VCM VSS nfet_06v0 ad=8.8p pd=40.88u as=8.8p ps=40.88u w=20u l=0.7u
X41 FS_PB_BLEED_3 FS_PB_BLEED_4 VSS ppolyf_u_1k r_width=1u r_length=12.5u
X42 FS_P_OUT FS_P_GATE FS_P_WELL FS_P_WELL pfet_03v3 ad=6.16p pd=28.88u as=6.16p ps=28.88u w=14u l=0.28u
X43 TERM_P_R TERM_GATE_P TERM_VCM VSS nfet_06v0 ad=8.8p pd=40.88u as=8.8p ps=40.88u w=20u l=0.7u
X44 ESD_RAIL a_41852_148519# VSS VSS nfet_06v0 ad=13.936p pd=54.12u as=13.936p ps=54.12u w=53.6u l=0.7u
X45 PULLUP_P_OUT PULLUP_P_GATE PULLUP_P_WELL PULLUP_P_WELL pfet_03v3 ad=8.8p pd=40.88u as=8.8p ps=40.88u w=20u l=0.28u
X46 a_41005_131825# a_53878_132105# ESD_RAIL ppolyf_u r_width=0.8u r_length=63.855u
X47 VSS a_41852_148519# ESD_RAIL VSS nfet_06v0 ad=23.584p pd=0.10808m as=13.936p ps=54.12u w=53.6u l=0.7u
X48 ESD_RAIL a_41852_148519# VSS VSS nfet_06v0 ad=13.936p pd=54.12u as=13.936p ps=54.12u w=53.6u l=0.7u
X49 FS_P_BLEED_2 FS_P_BLEED_3 VSS ppolyf_u_1k r_width=1u r_length=12.5u
X50 VSS a_41852_148519# ESD_RAIL VSS nfet_06v0 ad=13.936p pd=54.12u as=13.936p ps=54.12u w=53.6u l=0.7u
X51 ESD_RAIL a_42245_90628# VSS VSS nfet_06v0 ad=13p pd=50.52u as=13p ps=50.52u w=50u l=0.7u
X52 PULLDOWN_P_R PULLDOWN_P VSS VSS nfet_06v0 ad=3.52p pd=16.88u as=3.52p ps=16.88u w=8u l=0.7u
X53 ESD_RAIL a_41852_148519# VSS VSS nfet_06v0 ad=13.936p pd=54.12u as=13.936p ps=54.12u w=53.6u l=0.7u
X54 a_42245_90628# a_44789_117064# ESD_RAIL ESD_RAIL pfet_06v0 ad=1.3p pd=5.52u as=1.3p ps=5.52u w=5u l=0.7u
X55 HS_N_9 HS_PBIAS VDD VDD pfet_03v3 ad=8.8p pd=40.88u as=8.8p ps=40.88u w=20u l=1u
X56 PULLUP_P_OUT PULLUP_P_GATE PULLUP_P_WELL PULLUP_P_WELL pfet_03v3 ad=8.8p pd=40.88u as=8.8p ps=40.88u w=20u l=0.28u
X57 VDD PULLUP_P_GATE PULLUP_P_WELL PULLUP_P_WELL pfet_06v0 ad=8.8p pd=40.88u as=8.8p ps=40.88u w=20u l=0.55u
X58 TRIM_N_0_R TERM_TRIM0 TERM_VCM VSS nfet_06v0 ad=2.2p pd=10.88u as=2.2p ps=10.88u w=5u l=0.7u
X59 VSS a_42245_90628# ESD_RAIL VSS nfet_06v0 ad=13p pd=50.52u as=13p ps=50.52u w=50u l=0.7u
X60 ESD_RAIL a_42245_90628# VSS VSS nfet_06v0 ad=13p pd=50.52u as=13p ps=50.52u w=50u l=0.7u
X61 FS_P_OUT FS_PB_GATE FS_P_WELL FS_P_WELL pfet_03v3 ad=6.16p pd=28.88u as=6.16p ps=28.88u w=14u l=0.28u
X62 ESD_RAIL a_44789_117064# a_42245_90628# ESD_RAIL pfet_06v0 ad=1.3p pd=5.52u as=1.3p ps=5.52u w=5u l=0.7u
X63 a_42245_90628# a_44789_117064# ESD_RAIL ESD_RAIL pfet_06v0 ad=1.3p pd=5.52u as=1.3p ps=5.52u w=5u l=0.7u
D3 PAD_P ESD_RAIL diode_pd2nw_06v0 pj=51.8u area=22.5p
X64 VSS a_44789_117064# a_42245_90628# VSS nfet_06v0 ad=2.2p pd=10.88u as=1.3p ps=5.52u w=5u l=0.7u
X65 FS_N_OUT FS_N_GATE FS_N_WELL FS_N_WELL pfet_03v3 ad=6.16p pd=28.88u as=6.16p ps=28.88u w=14u l=0.28u
X66 FS_P_OUT FS_P_GATE FS_P_WELL FS_P_WELL pfet_03v3 ad=6.16p pd=28.88u as=6.16p ps=28.88u w=14u l=0.28u
X67 VSS a_41852_148519# ESD_RAIL VSS nfet_06v0 ad=13.936p pd=54.12u as=13.936p ps=54.12u w=53.6u l=0.7u
X68 ESD_RAIL a_41852_148519# VSS VSS nfet_06v0 ad=13.936p pd=54.12u as=13.936p ps=54.12u w=53.6u l=0.7u
X69 ESD_RAIL a_42245_90628# VSS VSS nfet_06v0 ad=13p pd=50.52u as=13p ps=50.52u w=50u l=0.7u
X70 ESD_RAIL a_41852_148519# VSS VSS nfet_06v0 ad=13.936p pd=54.12u as=13.936p ps=54.12u w=53.6u l=0.7u
X71 TERM_P_R DIFF_ENABLE TERM_N_R VSS nfet_06v0 ad=8.8p pd=40.88u as=8.8p ps=40.88u w=20u l=0.7u
X72 TERM_GATE_N LS_SLOW VSS VSS nfet_03v3 ad=0.88p pd=4.88u as=0.88p ps=4.88u w=2u l=0.28u
X73 HS_P_5 HS_PBIAS VDD VDD pfet_03v3 ad=8.8p pd=40.88u as=8.8p ps=40.88u w=20u l=1u
X74 VSS a_41852_148519# ESD_RAIL VSS nfet_06v0 ad=13.936p pd=54.12u as=13.936p ps=54.12u w=53.6u l=0.7u
X75 ESD_RAIL a_44789_117064# a_42245_90628# ESD_RAIL pfet_06v0 ad=1.3p pd=5.52u as=1.3p ps=5.52u w=5u l=0.7u
X76 ESD_RAIL a_42245_90628# VSS VSS nfet_06v0 ad=22p pd=0.10088m as=13p ps=50.52u w=50u l=0.7u
X77 VSS a_42245_90628# ESD_RAIL VSS nfet_06v0 ad=13p pd=50.52u as=13p ps=50.52u w=50u l=0.7u
X78 FS_NB_BLEED_2 FS_NB_BLEED_3 VSS ppolyf_u_1k r_width=1u r_length=12.5u
X79 FS_P_GATE FS_HIGH_P FS_P_WELL FS_P_WELL pfet_06v0 ad=7.04p pd=32.88u as=7.04p ps=32.88u w=16u l=0.55u
X80 FS_P_WELL FS_PB_BLEED_0 VSS ppolyf_u_1k r_width=1u r_length=12.5u
D4 VSS TERM_ENABLE diode_nd2ps_03v3 pj=7.28u area=3.3124p
X81 a_41005_132945# a_53878_133225# ESD_RAIL ppolyf_u r_width=0.8u r_length=63.855u
X82 FS_N_BLEED_1 FS_N_BLEED_2 VSS ppolyf_u_1k r_width=1u r_length=12.5u
X83 PAD_P TERM_P_R VSS ppolyf_u r_width=16u r_length=1.48u
X84 TERM_OR_P_S TERM_ENABLE VDD VDD pfet_03v3 ad=2.7808p pd=13.52u as=2.7808p ps=13.52u w=6.32u l=0.28u
X85 VDD FS_NB_GATE FS_N_WELL FS_N_WELL pfet_06v0 ad=6.16p pd=28.88u as=6.16p ps=28.88u w=14u l=0.55u
X86 VDD PULLUP_P_GATE PULLUP_P_WELL PULLUP_P_WELL pfet_06v0 ad=8.8p pd=40.88u as=8.8p ps=40.88u w=20u l=0.55u
X87 DIV_P DIV_LOW_P VSS ppolyf_u_1k r_width=1u r_length=2u
X88 ESD_RAIL a_41852_148519# VSS VSS nfet_06v0 ad=13.936p pd=54.12u as=13.936p ps=54.12u w=53.6u l=0.7u
X89 a_42245_90628# a_44789_117064# VSS VSS nfet_06v0 ad=1.3p pd=5.52u as=1.3p ps=5.52u w=5u l=0.7u
X90 ESD_RAIL a_44789_117064# a_42245_90628# ESD_RAIL pfet_06v0 ad=1.3p pd=5.52u as=1.3p ps=5.52u w=5u l=0.7u
X91 FS_P_OUT FS_P_GATE FS_P_WELL FS_P_WELL pfet_03v3 ad=6.16p pd=28.88u as=6.16p ps=28.88u w=14u l=0.28u
D5 PAD_N ESD_RAIL diode_pd2nw_06v0 pj=51.8u area=22.5p
X92 HS_N_9 HS_N PAD_N VSS nfet_06v0 ad=8.8p pd=40.88u as=8.8p ps=40.88u w=20u l=0.7u
X93 VSS a_41852_148519# ESD_RAIL VSS nfet_06v0 ad=13.936p pd=54.12u as=13.936p ps=54.12u w=53.6u l=0.7u
X94 ESD_RAIL a_41852_148519# VSS VSS nfet_06v0 ad=13.936p pd=54.12u as=13.936p ps=54.12u w=53.6u l=0.7u
X95 ESD_RAIL a_41852_148519# VSS VSS nfet_06v0 ad=13.936p pd=54.12u as=13.936p ps=54.12u w=53.6u l=0.7u
X96 VSS a_41852_148519# ESD_RAIL VSS nfet_06v0 ad=23.584p pd=0.10808m as=13.936p ps=54.12u w=53.6u l=0.7u
X97 a_42245_90628# a_44789_117064# ESD_RAIL ESD_RAIL pfet_06v0 ad=1.3p pd=5.52u as=2.2p ps=10.88u w=5u l=0.7u
X98 ESD_RAIL a_41852_148519# VSS VSS nfet_06v0 ad=13.936p pd=54.12u as=13.936p ps=54.12u w=53.6u l=0.7u
X99 TERM_OR_N_NS VCM_LOW_OK VSS VSS nfet_03v3 ad=2.7808p pd=13.52u as=2.7808p ps=13.52u w=6.32u l=0.28u
X100 a_43813_117064# a_41005_131545# VSS VSS nfet_06v0 ad=2.2p pd=10.88u as=2.2p ps=10.88u w=5u l=0.7u
X101 VSS a_41852_148519# ESD_RAIL VSS nfet_06v0 ad=13.936p pd=54.12u as=13.936p ps=54.12u w=53.6u l=0.7u
X102 HS_P_3 HS_PBIAS VDD VDD pfet_03v3 ad=8.8p pd=40.88u as=8.8p ps=40.88u w=20u l=1u
X103 VSS a_41852_148519# ESD_RAIL VSS nfet_06v0 ad=13.936p pd=54.12u as=13.936p ps=54.12u w=53.6u l=0.7u
X104 ESD_RAIL a_42245_90628# VSS VSS nfet_06v0 ad=13p pd=50.52u as=13p ps=50.52u w=50u l=0.7u
X105 VSS a_42245_90628# ESD_RAIL VSS nfet_06v0 ad=13p pd=50.52u as=22p ps=0.10088m w=50u l=0.7u
X106 a_42245_90628# a_44789_117064# VSS VSS nfet_06v0 ad=1.3p pd=5.52u as=1.3p ps=5.52u w=5u l=0.7u
X107 VSS a_41852_148519# ESD_RAIL VSS nfet_06v0 ad=13.936p pd=54.12u as=13.936p ps=54.12u w=53.6u l=0.7u
X108 VSS a_41852_148519# ESD_RAIL VSS nfet_06v0 ad=13.936p pd=54.12u as=13.936p ps=54.12u w=53.6u l=0.7u
X109 ESD_RAIL a_41852_148519# VSS VSS nfet_06v0 ad=13.936p pd=54.12u as=13.936p ps=54.12u w=53.6u l=0.7u
X110 VDD FS_NB_GATE FS_N_WELL FS_N_WELL pfet_06v0 ad=6.16p pd=28.88u as=6.16p ps=28.88u w=14u l=0.55u
X111 VSS a_43813_117064# a_44789_117064# VSS nfet_06v0 ad=1.3p pd=5.52u as=1.3p ps=5.52u w=5u l=0.7u
X112 a_42245_90628# a_44789_117064# ESD_RAIL ESD_RAIL pfet_06v0 ad=1.3p pd=5.52u as=1.3p ps=5.52u w=5u l=0.7u
X113 HS_P_11 HS_P PAD_P VSS nfet_06v0 ad=8.8p pd=40.88u as=8.8p ps=40.88u w=20u l=0.7u
X114 VSS a_42245_90628# ESD_RAIL VSS nfet_06v0 ad=13p pd=50.52u as=22p ps=0.10088m w=50u l=0.7u
X115 PAD_P PULLDOWN_P_R VSS ppolyf_u_1k r_width=1u r_length=14.2u
X116 VDD FS_NB_GATE FS_N_WELL FS_N_WELL pfet_06v0 ad=6.16p pd=28.88u as=6.16p ps=28.88u w=14u l=0.55u
X117 PAD_P BYPASS_ENABLE RX_P VSS nfet_06v0 ad=8.8p pd=40.88u as=8.8p ps=40.88u w=20u l=0.7u
X118 HS_N_6 HS_N PAD_N VSS nfet_06v0 ad=8.8p pd=40.88u as=8.8p ps=40.88u w=20u l=0.7u
X119 a_41005_134065# a_53878_134345# ESD_RAIL ppolyf_u r_width=0.8u r_length=63.855u
X120 VSS a_41852_148519# ESD_RAIL VSS nfet_06v0 ad=23.584p pd=0.10808m as=13.936p ps=54.12u w=53.6u l=0.7u
X121 FS_P_OUT FS_P_GATE FS_P_WELL FS_P_WELL pfet_03v3 ad=6.16p pd=28.88u as=6.16p ps=28.88u w=14u l=0.28u
D6 PAD_N ESD_RAIL diode_pd2nw_06v0 pj=51.8u area=22.5p
X122 ESD_RAIL a_41852_148519# VSS VSS nfet_06v0 ad=13.936p pd=54.12u as=13.936p ps=54.12u w=53.6u l=0.7u
X123 ESD_RAIL a_42245_90628# VSS VSS nfet_06v0 ad=13p pd=50.52u as=13p ps=50.52u w=50u l=0.7u
X124 ESD_RAIL a_41852_148519# VSS VSS nfet_06v0 ad=13.936p pd=54.12u as=13.936p ps=54.12u w=53.6u l=0.7u
X125 VSS a_43813_117064# a_44789_117064# VSS nfet_06v0 ad=1.3p pd=5.52u as=1.3p ps=5.52u w=5u l=0.7u
X126 ESD_RAIL a_41852_148519# VSS VSS nfet_06v0 ad=13.936p pd=54.12u as=23.584p ps=0.10808m w=53.6u l=0.7u
X127 FS_P_OUT FS_PB_GATE FS_P_WELL FS_P_WELL pfet_03v3 ad=6.16p pd=28.88u as=6.16p ps=28.88u w=14u l=0.28u
D7 PAD_P ESD_RAIL diode_pd2nw_06v0 pj=51.8u area=22.5p
X128 HS_N_7 HS_N PAD_N VSS nfet_06v0 ad=8.8p pd=40.88u as=8.8p ps=40.88u w=20u l=0.7u
X129 VSS a_42245_90628# ESD_RAIL VSS nfet_06v0 ad=13p pd=50.52u as=13p ps=50.52u w=50u l=0.7u
X130 FS_P_OUT FS_PB_GATE FS_P_WELL FS_P_WELL pfet_03v3 ad=6.16p pd=28.88u as=6.16p ps=28.88u w=14u l=0.28u
X131 ESD_RAIL a_42245_90628# VSS VSS nfet_06v0 ad=13p pd=50.52u as=13p ps=50.52u w=50u l=0.7u
X132 VSS a_41852_148519# ESD_RAIL VSS nfet_06v0 ad=13.936p pd=54.12u as=13.936p ps=54.12u w=53.6u l=0.7u
X133 TERM_N_R TERM_LSA_GATE_N TERM_VCM VSS nfet_06v0 ad=8.8p pd=40.88u as=8.8p ps=40.88u w=20u l=0.7u
X134 FS_NB_GATE FS_HIGH_N FS_N_WELL FS_N_WELL pfet_06v0 ad=7.04p pd=32.88u as=7.04p ps=32.88u w=16u l=0.55u
X135 ESD_RAIL a_41852_148519# VSS VSS nfet_06v0 ad=13.936p pd=54.12u as=13.936p ps=54.12u w=53.6u l=0.7u
X136 VDD FS_PB_GATE FS_P_WELL FS_P_WELL pfet_06v0 ad=6.16p pd=28.88u as=6.16p ps=28.88u w=14u l=0.55u
X137 ESD_RAIL a_41852_148519# VSS VSS nfet_06v0 ad=13.936p pd=54.12u as=13.936p ps=54.12u w=53.6u l=0.7u
X138 HS_N_2 HS_N PAD_N VSS nfet_06v0 ad=8.8p pd=40.88u as=8.8p ps=40.88u w=20u l=0.7u
X139 VSS a_41852_148519# ESD_RAIL VSS nfet_06v0 ad=13.936p pd=54.12u as=13.936p ps=54.12u w=53.6u l=0.7u
X140 VDD FS_PB_GATE FS_P_WELL FS_P_WELL pfet_06v0 ad=6.16p pd=28.88u as=6.16p ps=28.88u w=14u l=0.55u
X141 ESD_RAIL a_42245_90628# VSS VSS nfet_06v0 ad=13p pd=50.52u as=13p ps=50.52u w=50u l=0.7u
X142 VDD FS_NB_GATE FS_N_WELL FS_N_WELL pfet_06v0 ad=6.16p pd=28.88u as=6.16p ps=28.88u w=14u l=0.55u
X143 VDD FS_PB_GATE FS_P_WELL FS_P_WELL pfet_06v0 ad=6.16p pd=28.88u as=6.16p ps=28.88u w=14u l=0.55u
X144 VDD FS_NB_GATE FS_N_WELL FS_N_WELL pfet_06v0 ad=6.16p pd=28.88u as=6.16p ps=28.88u w=14u l=0.55u
X145 FS_P_OUT FS_PB_GATE FS_P_WELL FS_P_WELL pfet_03v3 ad=6.16p pd=28.88u as=6.16p ps=28.88u w=14u l=0.28u
X146 VSS a_41852_148519# ESD_RAIL VSS nfet_06v0 ad=13.936p pd=54.12u as=13.936p ps=54.12u w=53.6u l=0.7u
X147 FS_P_OUT FS_PB_GATE FS_P_WELL FS_P_WELL pfet_03v3 ad=6.16p pd=28.88u as=6.16p ps=28.88u w=14u l=0.28u
X148 FS_N_OUT PAD_N VSS ppolyf_s r_width=2u r_length=3.5u
X149 VSS a_41852_148519# ESD_RAIL VSS nfet_06v0 ad=13.936p pd=54.12u as=13.936p ps=54.12u w=53.6u l=0.7u
X150 VDD FS_N_GATE FS_N_WELL FS_N_WELL pfet_06v0 ad=6.16p pd=28.88u as=6.16p ps=28.88u w=14u l=0.55u
X151 FS_P_OUT FS_PB_GATE FS_P_WELL FS_P_WELL pfet_03v3 ad=6.16p pd=28.88u as=6.16p ps=28.88u w=14u l=0.28u
X152 HS_P_13 HS_PBIAS VDD VDD pfet_03v3 ad=8.8p pd=40.88u as=8.8p ps=40.88u w=20u l=1u
X153 ESD_RAIL a_41852_148519# VSS VSS nfet_06v0 ad=13.936p pd=54.12u as=13.936p ps=54.12u w=53.6u l=0.7u
X154 a_41005_131545# VSS cap_mim_2f0_m4m5_noshield c_width=14u c_length=14u
X155 ESD_RAIL a_41852_148519# VSS VSS nfet_06v0 ad=13.936p pd=54.12u as=13.936p ps=54.12u w=53.6u l=0.7u
X156 VDD FS_NB_GATE FS_N_WELL FS_N_WELL pfet_06v0 ad=6.16p pd=28.88u as=6.16p ps=28.88u w=14u l=0.55u
X157 TERM_GATE_N TERM_OR_N_B TERM_OR_N_PLS VDD pfet_03v3 ad=7.04p pd=32.88u as=7.04p ps=32.88u w=16u l=0.28u
X158 VDD FS_PB_GATE FS_P_WELL FS_P_WELL pfet_06v0 ad=6.16p pd=28.88u as=6.16p ps=28.88u w=14u l=0.55u
X159 FS_P_OUT FS_PB_GATE FS_P_WELL FS_P_WELL pfet_03v3 ad=6.16p pd=28.88u as=6.16p ps=28.88u w=14u l=0.28u
X160 PULLUP_P_BLEED_5 PULLUP_P_BLEED_6 VSS ppolyf_u_1k r_width=1u r_length=12.5u
X161 VDD PULLUP_P_GATE PULLUP_P_WELL PULLUP_P_WELL pfet_06v0 ad=8.8p pd=40.88u as=8.8p ps=40.88u w=20u l=0.55u
X162 ESD_RAIL a_41852_148519# VSS VSS nfet_06v0 ad=13.936p pd=54.12u as=13.936p ps=54.12u w=53.6u l=0.7u
X163 VDD FS_N_GATE FS_N_WELL FS_N_WELL pfet_06v0 ad=6.16p pd=28.88u as=6.16p ps=28.88u w=14u l=0.55u
X164 VDD FS_PB_GATE FS_P_WELL FS_P_WELL pfet_06v0 ad=6.16p pd=28.88u as=6.16p ps=28.88u w=14u l=0.55u
X165 TERM_GATE_N TERM_GATE_N_BLEED_0 VSS ppolyf_u_1k r_width=1u r_length=12.5u
X166 HS_N_13 HS_N PAD_N VSS nfet_06v0 ad=8.8p pd=40.88u as=8.8p ps=40.88u w=20u l=0.7u
X167 FS_P_GATE FS_HIGH_P FS_P_CONTROL_S VSS nfet_06v0 ad=3.52p pd=16.88u as=3.52p ps=16.88u w=8u l=0.7u
X168 FS_P_OUT FS_P_GATE FS_P_WELL FS_P_WELL pfet_03v3 ad=6.16p pd=28.88u as=6.16p ps=28.88u w=14u l=0.28u
X169 VDD PULLUP_P_GATE PULLUP_P_WELL PULLUP_P_WELL pfet_06v0 ad=8.8p pd=40.88u as=8.8p ps=40.88u w=20u l=0.55u
X170 VSS a_42245_90628# ESD_RAIL VSS nfet_06v0 ad=13p pd=50.52u as=13p ps=50.52u w=50u l=0.7u
X171 VSS a_41852_148519# ESD_RAIL VSS nfet_06v0 ad=13.936p pd=54.12u as=13.936p ps=54.12u w=53.6u l=0.7u
X172 VSS a_41852_148519# ESD_RAIL VSS nfet_06v0 ad=13.936p pd=54.12u as=13.936p ps=54.12u w=53.6u l=0.7u
X173 TRIM_P_2_R TERM_TRIM2 TERM_VCM VSS nfet_06v0 ad=8.8p pd=40.88u as=8.8p ps=40.88u w=20u l=0.7u
X174 ESD_RAIL a_41852_148519# VSS VSS nfet_06v0 ad=13.936p pd=54.12u as=13.936p ps=54.12u w=53.6u l=0.7u
X175 HS_P_7 HS_PBIAS VDD VDD pfet_03v3 ad=8.8p pd=40.88u as=8.8p ps=40.88u w=20u l=1u
X176 ESD_RAIL a_42245_90628# VSS VSS nfet_06v0 ad=13p pd=50.52u as=13p ps=50.52u w=50u l=0.7u
X177 HS_N_6 HS_PBIAS VDD VDD pfet_03v3 ad=8.8p pd=40.88u as=8.8p ps=40.88u w=20u l=1u
X178 VDD FS_P_GATE FS_P_WELL FS_P_WELL pfet_06v0 ad=6.16p pd=28.88u as=6.16p ps=28.88u w=14u l=0.55u
X179 VDD FS_PB_GATE FS_P_WELL FS_P_WELL pfet_06v0 ad=6.16p pd=28.88u as=6.16p ps=28.88u w=14u l=0.55u
X180 ESD_RAIL a_41852_148519# VSS VSS nfet_06v0 ad=13.936p pd=54.12u as=13.936p ps=54.12u w=53.6u l=0.7u
X181 TERM_N_R TERM_GATE_N TERM_VCM VSS nfet_06v0 ad=8.8p pd=40.88u as=8.8p ps=40.88u w=20u l=0.7u
X182 VSS a_41852_148519# ESD_RAIL VSS nfet_06v0 ad=23.584p pd=0.10808m as=13.936p ps=54.12u w=53.6u l=0.7u
X183 VDD FS_N_GATE FS_N_WELL FS_N_WELL pfet_06v0 ad=6.16p pd=28.88u as=6.16p ps=28.88u w=14u l=0.55u
X184 HS_N_12 HS_PBIAS VDD VDD pfet_03v3 ad=8.8p pd=40.88u as=8.8p ps=40.88u w=20u l=1u
X185 VDD FS_P_GATE FS_P_WELL FS_P_WELL pfet_06v0 ad=6.16p pd=28.88u as=6.16p ps=28.88u w=14u l=0.55u
X186 VSS a_41852_148519# ESD_RAIL VSS nfet_06v0 ad=13.936p pd=54.12u as=13.936p ps=54.12u w=53.6u l=0.7u
X187 HS_P_9 HS_PBIAS VDD VDD pfet_03v3 ad=8.8p pd=40.88u as=8.8p ps=40.88u w=20u l=1u
X188 VSS a_41852_148519# ESD_RAIL VSS nfet_06v0 ad=13.936p pd=54.12u as=13.936p ps=54.12u w=53.6u l=0.7u
X189 ESD_RAIL a_41852_148519# VSS VSS nfet_06v0 ad=13.936p pd=54.12u as=13.936p ps=54.12u w=53.6u l=0.7u
X190 ESD_RAIL a_41852_148519# VSS VSS nfet_06v0 ad=13.936p pd=54.12u as=23.584p ps=0.10808m w=53.6u l=0.7u
X191 VSS a_42245_90628# ESD_RAIL VSS nfet_06v0 ad=13p pd=50.52u as=13p ps=50.52u w=50u l=0.7u
X192 ESD_RAIL a_42245_90628# VSS VSS nfet_06v0 ad=13p pd=50.52u as=13p ps=50.52u w=50u l=0.7u
X193 PULLUP_P_BLEED_1 PULLUP_P_BLEED_2 VSS ppolyf_u_1k r_width=1u r_length=12.5u
X194 FS_P_OUT FS_P_GATE FS_P_WELL FS_P_WELL pfet_03v3 ad=6.16p pd=28.88u as=6.16p ps=28.88u w=14u l=0.28u
X195 TRIM_P_0_R TERM_TRIM0 TERM_VCM VSS nfet_06v0 ad=2.2p pd=10.88u as=2.2p ps=10.88u w=5u l=0.7u
X196 VDD FS_N_GATE FS_N_WELL FS_N_WELL pfet_06v0 ad=6.16p pd=28.88u as=6.16p ps=28.88u w=14u l=0.55u
X197 PULLUP_P_OUT PAD_P VSS ppolyf_u_1k r_width=1u r_length=1.18u
X198 VSS a_41852_148519# ESD_RAIL VSS nfet_06v0 ad=13.936p pd=54.12u as=13.936p ps=54.12u w=53.6u l=0.7u
X199 PULLUP_P_CONTROL_S VDD VSS VSS nfet_06v0 ad=1.76p pd=8.88u as=1.76p ps=8.88u w=4u l=0.7u
X200 VSS a_41852_148519# ESD_RAIL VSS nfet_06v0 ad=23.584p pd=0.10808m as=13.936p ps=54.12u w=53.6u l=0.7u
X201 FS_P_OUT FS_P_GATE FS_P_WELL FS_P_WELL pfet_03v3 ad=6.16p pd=28.88u as=6.16p ps=28.88u w=14u l=0.28u
X202 VDD FS_N_GATE FS_N_WELL FS_N_WELL pfet_06v0 ad=6.16p pd=28.88u as=6.16p ps=28.88u w=14u l=0.55u
X203 HS_N_4 HS_PBIAS VDD VDD pfet_03v3 ad=8.8p pd=40.88u as=8.8p ps=40.88u w=20u l=1u
X204 VDD FS_P_GATE FS_P_WELL FS_P_WELL pfet_06v0 ad=6.16p pd=28.88u as=6.16p ps=28.88u w=14u l=0.55u
X205 ESD_RAIL a_42245_90628# VSS VSS nfet_06v0 ad=13p pd=50.52u as=13p ps=50.52u w=50u l=0.7u
X206 TERM_N_R TERM_GATE_N TERM_VCM VSS nfet_06v0 ad=8.8p pd=40.88u as=8.8p ps=40.88u w=20u l=0.7u
X207 PAD_P TRIM_P_2_R VSS ppolyf_u r_width=16u r_length=2.4u
X208 TERM_P_R TERM_LSA_GATE_P TERM_VCM VSS nfet_06v0 ad=8.8p pd=40.88u as=8.8p ps=40.88u w=20u l=0.7u
X209 VSS a_41852_148519# ESD_RAIL VSS nfet_06v0 ad=13.936p pd=54.12u as=13.936p ps=54.12u w=53.6u l=0.7u
X210 FS_PB_GATE FS_HIGH_P FS_P_WELL FS_P_WELL pfet_06v0 ad=7.04p pd=32.88u as=7.04p ps=32.88u w=16u l=0.55u
X211 VSS a_41852_148519# ESD_RAIL VSS nfet_06v0 ad=13.936p pd=54.12u as=13.936p ps=54.12u w=53.6u l=0.7u
X212 PULLUP_N_GATE PULLUP_N PULLUP_N_CONTROL_S VSS nfet_06v0 ad=0.88p pd=4.88u as=0.88p ps=4.88u w=2u l=0.7u
X213 VSS a_42245_90628# ESD_RAIL VSS nfet_06v0 ad=13p pd=50.52u as=13p ps=50.52u w=50u l=0.7u
X214 ESD_RAIL a_41852_148519# VSS VSS nfet_06v0 ad=13.936p pd=54.12u as=13.936p ps=54.12u w=53.6u l=0.7u
X215 ESD_RAIL a_41852_148519# VSS VSS nfet_06v0 ad=13.936p pd=54.12u as=13.936p ps=54.12u w=53.6u l=0.7u
X216 ESD_RAIL a_42245_90628# VSS VSS nfet_06v0 ad=13p pd=50.52u as=13p ps=50.52u w=50u l=0.7u
D8 VSS ESD_RAIL diode_nd2ps_06v0 pj=82u area=40p
X217 ESD_RAIL a_41852_148519# VSS VSS nfet_06v0 ad=13.936p pd=54.12u as=13.936p ps=54.12u w=53.6u l=0.7u
X218 a_44789_117064# a_43813_117064# VSS VSS nfet_06v0 ad=1.3p pd=5.52u as=2.2p ps=10.88u w=5u l=0.7u
X219 ESD_RAIL a_41852_148519# VSS VSS nfet_06v0 ad=13.936p pd=54.12u as=13.936p ps=54.12u w=53.6u l=0.7u
X220 VSS a_42245_90628# ESD_RAIL VSS nfet_06v0 ad=13p pd=50.52u as=13p ps=50.52u w=50u l=0.7u
X221 FS_NB_BLEED_3 FS_NB_BLEED_4 VSS ppolyf_u_1k r_width=1u r_length=12.5u
X222 VDD FS_P_GATE FS_P_WELL FS_P_WELL pfet_06v0 ad=6.16p pd=28.88u as=6.16p ps=28.88u w=14u l=0.55u
D9 VSS ESD_RAIL diode_nd2ps_06v0 pj=82u area=40p
X223 ESD_RAIL a_41852_148519# VSS VSS nfet_06v0 ad=13.936p pd=54.12u as=13.936p ps=54.12u w=53.6u l=0.7u
X224 VSS a_41852_148519# ESD_RAIL VSS nfet_06v0 ad=13.936p pd=54.12u as=13.936p ps=54.12u w=53.6u l=0.7u
X225 FS_N_BLEED_2 FS_N_BLEED_3 VSS ppolyf_u_1k r_width=1u r_length=12.5u
X226 PAD_N DIV_N VSS ppolyf_u_1k r_width=1u r_length=2u
X227 VDD FS_PB_GATE FS_P_WELL FS_P_WELL pfet_06v0 ad=6.16p pd=28.88u as=6.16p ps=28.88u w=14u l=0.55u
X228 TERM_LSA_GATE_N TERM_OR_N_B VSS VSS nfet_03v3 ad=1.76p pd=8.88u as=1.76p ps=8.88u w=4u l=0.28u
X229 FS_PB_BLEED_6 FS_PB_GATE VSS ppolyf_u_1k r_width=1u r_length=12.5u
X230 a_41852_148519# VSS VSS ppolyf_u_1k_6p0 r_width=1u r_length=6u
D10 PAD_P ESD_RAIL diode_pd2nw_06v0 pj=51.8u area=22.5p
X231 VSS a_41852_148519# ESD_RAIL VSS nfet_06v0 ad=13.936p pd=54.12u as=13.936p ps=54.12u w=53.6u l=0.7u
X232 ESD_RAIL a_41852_148519# VSS VSS nfet_06v0 ad=13.936p pd=54.12u as=13.936p ps=54.12u w=53.6u l=0.7u
X233 FS_NB_CONTROL_LS VDD VSS VSS nfet_06v0 ad=7.04p pd=32.88u as=7.04p ps=32.88u w=16u l=0.7u
X234 VDD FS_PB_GATE FS_P_WELL FS_P_WELL pfet_06v0 ad=6.16p pd=28.88u as=6.16p ps=28.88u w=14u l=0.55u
X235 FS_P_BLEED_5 FS_P_BLEED_6 VSS ppolyf_u_1k r_width=1u r_length=12.5u
X236 VSS a_41852_148519# ESD_RAIL VSS nfet_06v0 ad=13.936p pd=54.12u as=13.936p ps=54.12u w=53.6u l=0.7u
X237 ESD_RAIL a_42245_90628# VSS VSS nfet_06v0 ad=13p pd=50.52u as=13p ps=50.52u w=50u l=0.7u
X238 VSS a_41852_148519# ESD_RAIL VSS nfet_06v0 ad=23.584p pd=0.10808m as=13.936p ps=54.12u w=53.6u l=0.7u
X239 VSS a_41852_148519# ESD_RAIL VSS nfet_06v0 ad=13.936p pd=54.12u as=13.936p ps=54.12u w=53.6u l=0.7u
X240 a_41005_131825# a_53878_131545# ESD_RAIL ppolyf_u r_width=0.8u r_length=63.855u
X241 TERM_P_R DIFF_ENABLE TERM_N_R VSS nfet_06v0 ad=8.8p pd=40.88u as=8.8p ps=40.88u w=20u l=0.7u
X242 ESD_RAIL a_41852_148519# VSS VSS nfet_06v0 ad=13.936p pd=54.12u as=23.584p ps=0.10808m w=53.6u l=0.7u
X243 FS_NB_BLEED_1 FS_NB_BLEED_2 VSS ppolyf_u_1k r_width=1u r_length=12.5u
X244 VSS a_41852_148519# ESD_RAIL VSS nfet_06v0 ad=13.936p pd=54.12u as=13.936p ps=54.12u w=53.6u l=0.7u
X245 FS_N_BLEED_0 FS_N_BLEED_1 VSS ppolyf_u_1k r_width=1u r_length=12.5u
X246 ESD_RAIL a_41852_148519# VSS VSS nfet_06v0 ad=13.936p pd=54.12u as=13.936p ps=54.12u w=53.6u l=0.7u
X247 LS_SLOW_B LS_SLOW VDD VDD pfet_03v3 ad=1.76p pd=8.88u as=1.76p ps=8.88u w=4u l=0.28u
X248 PULLUP_P_GATE VDD PULLUP_P_WELL PULLUP_P_WELL pfet_06v0 ad=1.76p pd=8.88u as=1.76p ps=8.88u w=4u l=0.55u
X249 ESD_RAIL a_41852_148519# VSS VSS nfet_06v0 ad=13.936p pd=54.12u as=13.936p ps=54.12u w=53.6u l=0.7u
X250 PULLUP_N_BLEED_6 PULLUP_N_GATE VSS ppolyf_u_1k r_width=1u r_length=12.5u
X251 TERM_OR_N_S TERM_ENABLE VDD VDD pfet_03v3 ad=2.7808p pd=13.52u as=2.7808p ps=13.52u w=6.32u l=0.28u
X252 VSS a_41852_148519# ESD_RAIL VSS nfet_06v0 ad=13.936p pd=54.12u as=13.936p ps=54.12u w=53.6u l=0.7u
X253 ESD_RAIL a_41852_148519# VSS VSS nfet_06v0 ad=13.936p pd=54.12u as=13.936p ps=54.12u w=53.6u l=0.7u
X254 VSS a_42245_90628# ESD_RAIL VSS nfet_06v0 ad=13p pd=50.52u as=13p ps=50.52u w=50u l=0.7u
X255 VSS a_41852_148519# ESD_RAIL VSS nfet_06v0 ad=13.936p pd=54.12u as=13.936p ps=54.12u w=53.6u l=0.7u
X256 ESD_RAIL a_44789_117064# a_42245_90628# ESD_RAIL pfet_06v0 ad=1.3p pd=5.52u as=1.3p ps=5.52u w=5u l=0.7u
X257 VSS a_41852_148519# ESD_RAIL VSS nfet_06v0 ad=13.936p pd=54.12u as=13.936p ps=54.12u w=53.6u l=0.7u
X258 HS_N_8 HS_PBIAS VDD VDD pfet_03v3 ad=8.8p pd=40.88u as=8.8p ps=40.88u w=20u l=1u
X259 VSS a_41852_148519# ESD_RAIL VSS nfet_06v0 ad=13.936p pd=54.12u as=13.936p ps=54.12u w=53.6u l=0.7u
X260 a_41005_132945# a_53878_132665# ESD_RAIL ppolyf_u r_width=0.8u r_length=63.855u
X261 VDD FS_P_GATE FS_P_WELL FS_P_WELL pfet_06v0 ad=6.16p pd=28.88u as=6.16p ps=28.88u w=14u l=0.55u
D11 VSS PAD_P diode_nd2ps_06v0 pj=51.8u area=22.5p
X262 HS_P_10 HS_P PAD_P VSS nfet_06v0 ad=8.8p pd=40.88u as=8.8p ps=40.88u w=20u l=0.7u
X263 TERM_N_R TERM_GATE_N TERM_VCM VSS nfet_06v0 ad=8.8p pd=40.88u as=8.8p ps=40.88u w=20u l=0.7u
X264 ESD_RAIL a_41852_148519# VSS VSS nfet_06v0 ad=13.936p pd=54.12u as=13.936p ps=54.12u w=53.6u l=0.7u
X265 PAD_N PULLDOWN_N_R VSS ppolyf_u_1k r_width=1u r_length=14.2u
X266 ESD_RAIL a_42245_90628# VSS VSS nfet_06v0 ad=13p pd=50.52u as=13p ps=50.52u w=50u l=0.7u
X267 PAD_P BYPASS_ENABLE RX_P VSS nfet_06v0 ad=8.8p pd=40.88u as=8.8p ps=40.88u w=20u l=0.7u
X268 PULLUP_N_BLEED_0 PULLUP_N_BLEED_1 VSS ppolyf_u_1k r_width=1u r_length=12.5u
X269 HS_P_5 HS_P PAD_P VSS nfet_06v0 ad=8.8p pd=40.88u as=8.8p ps=40.88u w=20u l=0.7u
X270 TERM_GATE_P TERM_OR_P_B VSS VSS nfet_03v3 ad=4.4p pd=20.88u as=4.4p ps=20.88u w=10u l=0.28u
X271 ESD_RAIL a_41852_148519# VSS VSS nfet_06v0 ad=13.936p pd=54.12u as=13.936p ps=54.12u w=53.6u l=0.7u
X272 FS_PB_GATE VDD FS_P_WELL FS_P_WELL pfet_06v0 ad=1.76p pd=8.88u as=1.76p ps=8.88u w=4u l=0.55u
X273 TERM_GATE_N_BLEED_2 VSS VSS ppolyf_u_1k r_width=1u r_length=12.5u
X274 VSS a_42245_90628# ESD_RAIL VSS nfet_06v0 ad=13p pd=50.52u as=13p ps=50.52u w=50u l=0.7u
X275 TERM_GATE_P TERM_GATE_P_BLEED_0 VSS ppolyf_u_1k r_width=1u r_length=12.5u
X276 VSS a_41852_148519# ESD_RAIL VSS nfet_06v0 ad=13.936p pd=54.12u as=13.936p ps=54.12u w=53.6u l=0.7u
X277 DIV_P DIV_ENABLE RX_P VSS nfet_06v0 ad=8.8p pd=40.88u as=8.8p ps=40.88u w=20u l=0.7u
X278 VSS a_41852_148519# ESD_RAIL VSS nfet_06v0 ad=13.936p pd=54.12u as=13.936p ps=54.12u w=53.6u l=0.7u
X279 VSS a_42245_90628# ESD_RAIL VSS nfet_06v0 ad=13p pd=50.52u as=13p ps=50.52u w=50u l=0.7u
X280 ESD_RAIL a_41852_148519# VSS VSS nfet_06v0 ad=13.936p pd=54.12u as=23.584p ps=0.10808m w=53.6u l=0.7u
X281 PULLUP_N_BLEED_2 PULLUP_N_BLEED_3 VSS ppolyf_u_1k r_width=1u r_length=12.5u
X282 ESD_RAIL a_41852_148519# VSS VSS nfet_06v0 ad=13.936p pd=54.12u as=23.584p ps=0.10808m w=53.6u l=0.7u
X283 ESD_RAIL a_41852_148519# VSS VSS nfet_06v0 ad=13.936p pd=54.12u as=13.936p ps=54.12u w=53.6u l=0.7u
X284 HS_P_6 HS_P PAD_P VSS nfet_06v0 ad=8.8p pd=40.88u as=8.8p ps=40.88u w=20u l=0.7u
X285 ESD_RAIL a_42245_90628# VSS VSS nfet_06v0 ad=13p pd=50.52u as=13p ps=50.52u w=50u l=0.7u
X286 FS_N_OUT FS_NB_GATE FS_N_WELL FS_N_WELL pfet_03v3 ad=6.16p pd=28.88u as=6.16p ps=28.88u w=14u l=0.28u
X287 VSS a_41852_148519# ESD_RAIL VSS nfet_06v0 ad=13.936p pd=54.12u as=13.936p ps=54.12u w=53.6u l=0.7u
X288 VSS a_41852_148519# ESD_RAIL VSS nfet_06v0 ad=13.936p pd=54.12u as=13.936p ps=54.12u w=53.6u l=0.7u
X289 TRIM_N_1_R TERM_TRIM1 TERM_VCM VSS nfet_06v0 ad=4.4p pd=20.88u as=4.4p ps=20.88u w=10u l=0.7u
X290 TERM_N_R TERM_LSA_GATE_N TERM_VCM VSS nfet_06v0 ad=8.8p pd=40.88u as=8.8p ps=40.88u w=20u l=0.7u
X291 VSS a_41852_148519# ESD_RAIL VSS nfet_06v0 ad=13.936p pd=54.12u as=13.936p ps=54.12u w=53.6u l=0.7u
D12 PAD_P ESD_RAIL diode_pd2nw_06v0 pj=51.8u area=22.5p
X292 FS_N_OUT FS_NB_GATE FS_N_WELL FS_N_WELL pfet_03v3 ad=6.16p pd=28.88u as=6.16p ps=28.88u w=14u l=0.28u
X293 a_42245_90628# a_44789_117064# ESD_RAIL ESD_RAIL pfet_06v0 ad=1.3p pd=5.52u as=1.3p ps=5.52u w=5u l=0.7u
X294 a_43813_117064# a_41005_131545# ESD_RAIL ESD_RAIL pfet_06v0 ad=1.3p pd=5.52u as=1.3p ps=5.52u w=5u l=0.7u
X295 VSS a_41852_148519# ESD_RAIL VSS nfet_06v0 ad=13.936p pd=54.12u as=13.936p ps=54.12u w=53.6u l=0.7u
X296 FS_P_CONTROL_S VDD VSS VSS nfet_06v0 ad=7.04p pd=32.88u as=7.04p ps=32.88u w=16u l=0.7u
X297 ESD_RAIL a_41852_148519# VSS VSS nfet_06v0 ad=13.936p pd=54.12u as=13.936p ps=54.12u w=53.6u l=0.7u
X298 ESD_RAIL a_41852_148519# VSS VSS nfet_06v0 ad=13.936p pd=54.12u as=13.936p ps=54.12u w=53.6u l=0.7u
X299 VSS a_41852_148519# ESD_RAIL VSS nfet_06v0 ad=13.936p pd=54.12u as=13.936p ps=54.12u w=53.6u l=0.7u
X300 ESD_RAIL a_41852_148519# VSS VSS nfet_06v0 ad=13.936p pd=54.12u as=23.584p ps=0.10808m w=53.6u l=0.7u
X301 ESD_RAIL a_41852_148519# VSS VSS nfet_06v0 ad=13.936p pd=54.12u as=23.584p ps=0.10808m w=53.6u l=0.7u
X302 a_44789_117064# a_43813_117064# ESD_RAIL ESD_RAIL pfet_06v0 ad=2.2p pd=10.88u as=1.3p ps=5.52u w=5u l=0.7u
X303 ESD_RAIL a_41852_148519# VSS VSS nfet_06v0 ad=13.936p pd=54.12u as=13.936p ps=54.12u w=53.6u l=0.7u
X304 HS_P_3 HS_P PAD_P VSS nfet_06v0 ad=8.8p pd=40.88u as=8.8p ps=40.88u w=20u l=0.7u
X305 VDD FS_P_GATE FS_P_WELL FS_P_WELL pfet_06v0 ad=6.16p pd=28.88u as=6.16p ps=28.88u w=14u l=0.55u
X306 TRIM_P_1_R TERM_TRIM1 TERM_VCM VSS nfet_06v0 ad=4.4p pd=20.88u as=4.4p ps=20.88u w=10u l=0.7u
D13 VSS PAD_N diode_nd2ps_06v0 pj=51.8u area=22.5p
X307 ESD_RAIL a_42245_90628# VSS VSS nfet_06v0 ad=13p pd=50.52u as=13p ps=50.52u w=50u l=0.7u
X308 VSS a_41852_148519# ESD_RAIL VSS nfet_06v0 ad=23.584p pd=0.10808m as=13.936p ps=54.12u w=53.6u l=0.7u
X309 FS_NB_BLEED_5 FS_NB_BLEED_6 VSS ppolyf_u_1k r_width=1u r_length=12.5u
X310 FS_N_OUT FS_NB_GATE FS_N_WELL FS_N_WELL pfet_03v3 ad=6.16p pd=28.88u as=6.16p ps=28.88u w=14u l=0.28u
X311 FS_NB_CONTROL_S LS_SLOW_B FS_NB_CONTROL_LS VSS nfet_03v3 ad=7.04p pd=32.88u as=7.04p ps=32.88u w=16u l=0.28u
X312 FS_N_BLEED_4 FS_N_BLEED_5 VSS ppolyf_u_1k r_width=1u r_length=12.5u
X313 FS_N_OUT FS_NB_GATE FS_N_WELL FS_N_WELL pfet_03v3 ad=6.16p pd=28.88u as=6.16p ps=28.88u w=14u l=0.28u
X314 TERM_OR_N_PLS LS_SLOW VDD VDD pfet_03v3 ad=7.04p pd=32.88u as=7.04p ps=32.88u w=16u l=0.28u
X315 ESD_RAIL a_41852_148519# VSS VSS nfet_06v0 ad=13.936p pd=54.12u as=13.936p ps=54.12u w=53.6u l=0.7u
X316 HS_N_13 HS_PBIAS VDD VDD pfet_03v3 ad=8.8p pd=40.88u as=8.8p ps=40.88u w=20u l=1u
X317 TERM_P_R TERM_GATE_P TERM_VCM VSS nfet_06v0 ad=8.8p pd=40.88u as=8.8p ps=40.88u w=20u l=0.7u
X318 VSS a_42245_90628# ESD_RAIL VSS nfet_06v0 ad=13p pd=50.52u as=13p ps=50.52u w=50u l=0.7u
X319 PULLUP_P_GATE PULLUP_P PULLUP_P_CONTROL_S VSS nfet_06v0 ad=0.88p pd=4.88u as=0.88p ps=4.88u w=2u l=0.7u
X320 VSS ESD_RAIL VSS ppolyf_u_1k_6p0 r_width=1u r_length=9.98874m
X321 VSS a_41852_148519# ESD_RAIL VSS nfet_06v0 ad=13.936p pd=54.12u as=13.936p ps=54.12u w=53.6u l=0.7u
X322 PULLUP_N_OUT PULLUP_N_GATE PULLUP_N_WELL PULLUP_N_WELL pfet_03v3 ad=8.8p pd=40.88u as=8.8p ps=40.88u w=20u l=0.28u
X323 ESD_RAIL a_41852_148519# VSS VSS nfet_06v0 ad=13.936p pd=54.12u as=23.584p ps=0.10808m w=53.6u l=0.7u
X324 HS_P_12 HS_P PAD_P VSS nfet_06v0 ad=8.8p pd=40.88u as=8.8p ps=40.88u w=20u l=0.7u
X325 VSS a_41852_148519# ESD_RAIL VSS nfet_06v0 ad=13.936p pd=54.12u as=13.936p ps=54.12u w=53.6u l=0.7u
X326 FS_N_BLEED_6 FS_N_GATE VSS ppolyf_u_1k r_width=1u r_length=12.5u
X327 ESD_RAIL a_44789_117064# a_42245_90628# ESD_RAIL pfet_06v0 ad=2.2p pd=10.88u as=1.3p ps=5.52u w=5u l=0.7u
X328 a_42245_90628# a_44789_117064# ESD_RAIL ESD_RAIL pfet_06v0 ad=1.3p pd=5.52u as=1.3p ps=5.52u w=5u l=0.7u
X329 VSS a_42245_90628# ESD_RAIL VSS nfet_06v0 ad=13p pd=50.52u as=13p ps=50.52u w=50u l=0.7u
X330 VSS a_41852_148519# ESD_RAIL VSS nfet_06v0 ad=13.936p pd=54.12u as=13.936p ps=54.12u w=53.6u l=0.7u
X331 ESD_RAIL a_41852_148519# VSS VSS nfet_06v0 ad=13.936p pd=54.12u as=13.936p ps=54.12u w=53.6u l=0.7u
X332 VSS a_41852_148519# ESD_RAIL VSS nfet_06v0 ad=13.936p pd=54.12u as=13.936p ps=54.12u w=53.6u l=0.7u
X333 TERM_OR_N_B FS_LOW_N TERM_OR_N_NS VSS nfet_03v3 ad=1.3904p pd=7.2u as=1.3904p ps=7.2u w=3.16u l=0.28u
X334 FS_N_OUT FS_N_GATE FS_N_WELL FS_N_WELL pfet_03v3 ad=6.16p pd=28.88u as=6.16p ps=28.88u w=14u l=0.28u
X335 DIV_N DIV_ENABLE RX_N VSS nfet_06v0 ad=8.8p pd=40.88u as=8.8p ps=40.88u w=20u l=0.7u
X336 a_41005_134065# a_53878_133785# ESD_RAIL ppolyf_u r_width=0.8u r_length=63.855u
X337 HS_P_6 HS_PBIAS VDD VDD pfet_03v3 ad=8.8p pd=40.88u as=8.8p ps=40.88u w=20u l=1u
X338 ESD_RAIL a_41852_148519# VSS VSS nfet_06v0 ad=13.936p pd=54.12u as=13.936p ps=54.12u w=53.6u l=0.7u
X339 ESD_RAIL a_41852_148519# VSS VSS nfet_06v0 ad=13.936p pd=54.12u as=13.936p ps=54.12u w=53.6u l=0.7u
X340 VSS a_42245_90628# ESD_RAIL VSS nfet_06v0 ad=13p pd=50.52u as=13p ps=50.52u w=50u l=0.7u
X341 ESD_RAIL a_41852_148519# VSS VSS nfet_06v0 ad=13.936p pd=54.12u as=13.936p ps=54.12u w=53.6u l=0.7u
X342 HS_N_11 HS_PBIAS VDD VDD pfet_03v3 ad=8.8p pd=40.88u as=8.8p ps=40.88u w=20u l=1u
X343 PULLUP_P_OUT PULLUP_P_GATE PULLUP_P_WELL PULLUP_P_WELL pfet_03v3 ad=8.8p pd=40.88u as=8.8p ps=40.88u w=20u l=0.28u
X344 ESD_RAIL a_41852_148519# VSS VSS nfet_06v0 ad=13.936p pd=54.12u as=13.936p ps=54.12u w=53.6u l=0.7u
X345 VSS a_42245_90628# ESD_RAIL VSS nfet_06v0 ad=13p pd=50.52u as=13p ps=50.52u w=50u l=0.7u
X346 ESD_RAIL a_44789_117064# a_42245_90628# ESD_RAIL pfet_06v0 ad=1.3p pd=5.52u as=1.3p ps=5.52u w=5u l=0.7u
D14 VSS FS_LOW_P diode_nd2ps_03v3 pj=9.16u area=5.2441p
X347 HS_P_8 HS_PBIAS VDD VDD pfet_03v3 ad=8.8p pd=40.88u as=8.8p ps=40.88u w=20u l=1u
X348 VSS a_41852_148519# ESD_RAIL VSS nfet_06v0 ad=13.936p pd=54.12u as=13.936p ps=54.12u w=53.6u l=0.7u
X349 VSS RX_P VSS ppolyf_u_1k_6p0 r_width=1u r_length=0.31954m
X350 ESD_RAIL a_41852_148519# VSS VSS nfet_06v0 ad=13.936p pd=54.12u as=23.584p ps=0.10808m w=53.6u l=0.7u
X351 ESD_RAIL a_41852_148519# cap_mim_2f0_m4m5_noshield c_width=90u c_length=90u
X352 ESD_RAIL a_42245_90628# VSS VSS nfet_06v0 ad=13p pd=50.52u as=13p ps=50.52u w=50u l=0.7u
X353 TERM_OR_N_B VCM_LOW_OK TERM_OR_N_S VDD pfet_03v3 ad=2.7808p pd=13.52u as=2.7808p ps=13.52u w=6.32u l=0.28u
X354 ESD_RAIL a_41852_148519# VSS VSS nfet_06v0 ad=13.936p pd=54.12u as=13.936p ps=54.12u w=53.6u l=0.7u
D15 VSS ESD_RAIL diode_nd2ps_06v0 pj=82u area=40p
X355 PULLUP_P_BLEED_0 PULLUP_P_BLEED_1 VSS ppolyf_u_1k r_width=1u r_length=12.5u
X356 ESD_RAIL VSS cap_mim_2f0_m4m5_noshield c_width=31.6u c_length=31.6u
X357 ESD_RAIL a_43813_117064# a_44789_117064# ESD_RAIL pfet_06v0 ad=1.3p pd=5.52u as=1.3p ps=5.52u w=5u l=0.7u
X358 ESD_RAIL a_41852_148519# VSS VSS nfet_06v0 ad=13.936p pd=54.12u as=13.936p ps=54.12u w=53.6u l=0.7u
X359 VSS a_41852_148519# ESD_RAIL VSS nfet_06v0 ad=13.936p pd=54.12u as=13.936p ps=54.12u w=53.6u l=0.7u
X360 PULLUP_N_OUT PAD_N VSS ppolyf_u_1k r_width=1u r_length=1.18u
X361 FS_N_OUT FS_N_GATE FS_N_WELL FS_N_WELL pfet_03v3 ad=6.16p pd=28.88u as=6.16p ps=28.88u w=14u l=0.28u
X362 VSS a_41852_148519# ESD_RAIL VSS nfet_06v0 ad=13.936p pd=54.12u as=13.936p ps=54.12u w=53.6u l=0.7u
X363 VSS a_41852_148519# ESD_RAIL VSS nfet_06v0 ad=13.936p pd=54.12u as=13.936p ps=54.12u w=53.6u l=0.7u
X364 TERM_P_R DIFF_ENABLE TERM_N_R VSS nfet_06v0 ad=8.8p pd=40.88u as=8.8p ps=40.88u w=20u l=0.7u
X365 FS_PB_CONTROL_S LS_SLOW_B FS_PB_CONTROL_LS VSS nfet_03v3 ad=7.04p pd=32.88u as=7.04p ps=32.88u w=16u l=0.28u
X366 VSS a_41852_148519# ESD_RAIL VSS nfet_06v0 ad=13.936p pd=54.12u as=13.936p ps=54.12u w=53.6u l=0.7u
X367 PAD_P TRIM_P_0_R VSS ppolyf_u r_width=4u r_length=2.4u
D16 VSS PAD_N diode_nd2ps_06v0 pj=51.8u area=22.5p
X368 a_42245_90628# a_44789_117064# ESD_RAIL ESD_RAIL pfet_06v0 ad=1.3p pd=5.52u as=1.3p ps=5.52u w=5u l=0.7u
X369 FS_PB_BLEED_1 FS_PB_BLEED_2 VSS ppolyf_u_1k r_width=1u r_length=12.5u
X370 FS_N_OUT FS_NB_GATE FS_N_WELL FS_N_WELL pfet_03v3 ad=6.16p pd=28.88u as=6.16p ps=28.88u w=14u l=0.28u
X371 PAD_N TRIM_N_2_R VSS ppolyf_u r_width=16u r_length=2.4u
X372 PULLUP_P_OUT PULLUP_P_GATE PULLUP_P_WELL PULLUP_P_WELL pfet_03v3 ad=8.8p pd=40.88u as=8.8p ps=40.88u w=20u l=0.28u
X373 HS_P_2 HS_PBIAS VDD VDD pfet_03v3 ad=8.8p pd=40.88u as=8.8p ps=40.88u w=20u l=1u
X374 VSS a_41852_148519# ESD_RAIL VSS nfet_06v0 ad=13.936p pd=54.12u as=13.936p ps=54.12u w=53.6u l=0.7u
X375 FS_P_BLEED_0 FS_P_BLEED_1 VSS ppolyf_u_1k r_width=1u r_length=12.5u
X376 VSS a_41852_148519# ESD_RAIL VSS nfet_06v0 ad=13.936p pd=54.12u as=13.936p ps=54.12u w=53.6u l=0.7u
X377 VDD FS_NB_GATE FS_N_WELL FS_N_WELL pfet_06v0 ad=6.16p pd=28.88u as=6.16p ps=28.88u w=14u l=0.55u
X378 TERM_LSA_GATE_N VSS VSS ppolyf_u_1k r_width=1u r_length=12.5u
X379 ESD_RAIL a_41852_148519# VSS VSS nfet_06v0 ad=13.936p pd=54.12u as=13.936p ps=54.12u w=53.6u l=0.7u
X380 a_43813_117064# a_41005_131545# ESD_RAIL ESD_RAIL pfet_06v0 ad=1.3p pd=5.52u as=2.2p ps=10.88u w=5u l=0.7u
X381 VSS a_41852_148519# ESD_RAIL VSS nfet_06v0 ad=13.936p pd=54.12u as=13.936p ps=54.12u w=53.6u l=0.7u
X382 ESD_RAIL a_42245_90628# VSS VSS nfet_06v0 ad=22p pd=0.10088m as=13p ps=50.52u w=50u l=0.7u
X383 VSS a_41852_148519# ESD_RAIL VSS nfet_06v0 ad=13.936p pd=54.12u as=13.936p ps=54.12u w=53.6u l=0.7u
X384 DIV_N DIV_LOW_N VSS ppolyf_u_1k r_width=1u r_length=2u
X385 ESD_RAIL a_41852_148519# VSS VSS nfet_06v0 ad=13.936p pd=54.12u as=13.936p ps=54.12u w=53.6u l=0.7u
X386 ESD_RAIL a_42245_90628# VSS VSS nfet_06v0 ad=13p pd=50.52u as=13p ps=50.52u w=50u l=0.7u
X387 VSS a_42245_90628# ESD_RAIL VSS nfet_06v0 ad=13p pd=50.52u as=13p ps=50.52u w=50u l=0.7u
X388 TERM_LSA_GATE_P TERM_OR_P_B VDD VDD pfet_03v3 ad=3.52p pd=16.88u as=3.52p ps=16.88u w=8u l=0.28u
X389 VSS a_42245_90628# ESD_RAIL VSS nfet_06v0 ad=13p pd=50.52u as=13p ps=50.52u w=50u l=0.7u
X390 a_44789_117064# a_43813_117064# ESD_RAIL ESD_RAIL pfet_06v0 ad=1.3p pd=5.52u as=1.3p ps=5.52u w=5u l=0.7u
X391 ESD_RAIL a_41852_148519# VSS VSS nfet_06v0 ad=13.936p pd=54.12u as=13.936p ps=54.12u w=53.6u l=0.7u
X392 ESD_RAIL a_41852_148519# VSS VSS nfet_06v0 ad=13.936p pd=54.12u as=13.936p ps=54.12u w=53.6u l=0.7u
X393 ESD_RAIL a_41852_148519# VSS VSS nfet_06v0 ad=13.936p pd=54.12u as=13.936p ps=54.12u w=53.6u l=0.7u
X394 FS_N_OUT FS_NB_GATE FS_N_WELL FS_N_WELL pfet_03v3 ad=6.16p pd=28.88u as=6.16p ps=28.88u w=14u l=0.28u
X395 ESD_RAIL a_41852_148519# VSS VSS nfet_06v0 ad=13.936p pd=54.12u as=23.584p ps=0.10808m w=53.6u l=0.7u
X396 ESD_RAIL a_41852_148519# VSS VSS nfet_06v0 ad=13.936p pd=54.12u as=13.936p ps=54.12u w=53.6u l=0.7u
X397 FS_N_OUT FS_NB_GATE FS_N_WELL FS_N_WELL pfet_03v3 ad=6.16p pd=28.88u as=6.16p ps=28.88u w=14u l=0.28u
X398 VSS a_41852_148519# ESD_RAIL VSS nfet_06v0 ad=13.936p pd=54.12u as=13.936p ps=54.12u w=53.6u l=0.7u
X399 TERM_LSA_GATE_P TERM_OR_P_B VSS VSS nfet_03v3 ad=1.76p pd=8.88u as=1.76p ps=8.88u w=4u l=0.28u
X400 FS_PB_BLEED_5 FS_PB_BLEED_6 VSS ppolyf_u_1k r_width=1u r_length=12.5u
X401 FS_PB_CONTROL_LS VDD VSS VSS nfet_06v0 ad=7.04p pd=32.88u as=7.04p ps=32.88u w=16u l=0.7u
X402 VSS a_41852_148519# ESD_RAIL VSS nfet_06v0 ad=13.936p pd=54.12u as=13.936p ps=54.12u w=53.6u l=0.7u
X403 FS_P_BLEED_4 FS_P_BLEED_5 VSS ppolyf_u_1k r_width=1u r_length=12.5u
X404 ESD_RAIL a_41852_148519# VSS VSS nfet_06v0 ad=13.936p pd=54.12u as=13.936p ps=54.12u w=53.6u l=0.7u
X405 VSS a_41852_148519# ESD_RAIL VSS nfet_06v0 ad=13.936p pd=54.12u as=13.936p ps=54.12u w=53.6u l=0.7u
X406 FS_N_OUT FS_NB_GATE FS_N_WELL FS_N_WELL pfet_03v3 ad=6.16p pd=28.88u as=6.16p ps=28.88u w=14u l=0.28u
X407 VSS a_42245_90628# ESD_RAIL VSS nfet_06v0 ad=13p pd=50.52u as=22p ps=0.10088m w=50u l=0.7u
X408 ESD_RAIL a_44789_117064# a_42245_90628# ESD_RAIL pfet_06v0 ad=1.3p pd=5.52u as=1.3p ps=5.52u w=5u l=0.7u
X409 HS_N_8 HS_N PAD_N VSS nfet_06v0 ad=8.8p pd=40.88u as=8.8p ps=40.88u w=20u l=0.7u
X410 VSS a_42245_90628# ESD_RAIL VSS nfet_06v0 ad=13p pd=50.52u as=13p ps=50.52u w=50u l=0.7u
X411 ESD_RAIL a_41852_148519# VSS VSS nfet_06v0 ad=13.936p pd=54.12u as=13.936p ps=54.12u w=53.6u l=0.7u
X412 FS_N_OUT FS_NB_GATE FS_N_WELL FS_N_WELL pfet_03v3 ad=6.16p pd=28.88u as=6.16p ps=28.88u w=14u l=0.28u
X413 FS_PB_GATE FS_HIGH_P FS_PB_CONTROL_S VSS nfet_06v0 ad=3.52p pd=16.88u as=3.52p ps=16.88u w=8u l=0.7u
X414 VSS a_42245_90628# ESD_RAIL VSS nfet_06v0 ad=13p pd=50.52u as=13p ps=50.52u w=50u l=0.7u
X415 TERM_P_R TERM_LSA_GATE_P TERM_VCM VSS nfet_06v0 ad=8.8p pd=40.88u as=8.8p ps=40.88u w=20u l=0.7u
X416 ESD_RAIL a_41852_148519# VSS VSS nfet_06v0 ad=13.936p pd=54.12u as=13.936p ps=54.12u w=53.6u l=0.7u
X417 VSS a_41852_148519# ESD_RAIL VSS nfet_06v0 ad=13.936p pd=54.12u as=13.936p ps=54.12u w=53.6u l=0.7u
X418 VDD FS_NB_GATE FS_N_WELL FS_N_WELL pfet_06v0 ad=6.16p pd=28.88u as=6.16p ps=28.88u w=14u l=0.55u
X419 FS_N_GATE VDD FS_N_WELL FS_N_WELL pfet_06v0 ad=1.76p pd=8.88u as=1.76p ps=8.88u w=4u l=0.55u
X420 VSS a_41852_148519# ESD_RAIL VSS nfet_06v0 ad=13.936p pd=54.12u as=13.936p ps=54.12u w=53.6u l=0.7u
X421 VDD FS_NB_GATE FS_N_WELL FS_N_WELL pfet_06v0 ad=6.16p pd=28.88u as=6.16p ps=28.88u w=14u l=0.55u
X422 VDD PULLUP_N_GATE PULLUP_N_WELL PULLUP_N_WELL pfet_06v0 ad=8.8p pd=40.88u as=8.8p ps=40.88u w=20u l=0.55u
X423 VDD FS_NB_GATE FS_N_WELL FS_N_WELL pfet_06v0 ad=6.16p pd=28.88u as=6.16p ps=28.88u w=14u l=0.55u
X424 ESD_RAIL a_41852_148519# VSS VSS nfet_06v0 ad=13.936p pd=54.12u as=13.936p ps=54.12u w=53.6u l=0.7u
X425 ESD_RAIL a_41852_148519# VSS VSS nfet_06v0 ad=13.936p pd=54.12u as=13.936p ps=54.12u w=53.6u l=0.7u
X426 PULLUP_N_GATE VDD PULLUP_N_WELL PULLUP_N_WELL pfet_06v0 ad=1.76p pd=8.88u as=1.76p ps=8.88u w=4u l=0.55u
X427 VSS a_41852_148519# ESD_RAIL VSS nfet_06v0 ad=13.936p pd=54.12u as=13.936p ps=54.12u w=53.6u l=0.7u
X428 VDD FS_NB_GATE FS_N_WELL FS_N_WELL pfet_06v0 ad=6.16p pd=28.88u as=6.16p ps=28.88u w=14u l=0.55u
X429 VSS RX_N VSS ppolyf_u_1k_6p0 r_width=1u r_length=0.31954m
X430 TERM_GATE_P LS_SLOW VSS VSS nfet_03v3 ad=0.88p pd=4.88u as=0.88p ps=4.88u w=2u l=0.28u
X431 TERM_OR_P_B VCM_LOW_OK TERM_OR_P_S VDD pfet_03v3 ad=2.7808p pd=13.52u as=2.7808p ps=13.52u w=6.32u l=0.28u
X432 FS_N_OUT FS_N_GATE FS_N_WELL FS_N_WELL pfet_03v3 ad=6.16p pd=28.88u as=6.16p ps=28.88u w=14u l=0.28u
X433 ESD_RAIL a_41852_148519# VSS VSS nfet_06v0 ad=13.936p pd=54.12u as=13.936p ps=54.12u w=53.6u l=0.7u
D17 PAD_P ESD_RAIL diode_pd2nw_06v0 pj=51.8u area=22.5p
X434 ESD_RAIL a_42245_90628# VSS VSS nfet_06v0 ad=13p pd=50.52u as=13p ps=50.52u w=50u l=0.7u
X435 FS_N_OUT FS_NB_GATE FS_N_WELL FS_N_WELL pfet_03v3 ad=6.16p pd=28.88u as=6.16p ps=28.88u w=14u l=0.28u
X436 HS_N_7 HS_PBIAS VDD VDD pfet_03v3 ad=8.8p pd=40.88u as=8.8p ps=40.88u w=20u l=1u
X437 FS_P_OUT FS_PB_GATE FS_P_WELL FS_P_WELL pfet_03v3 ad=6.16p pd=28.88u as=6.16p ps=28.88u w=14u l=0.28u
X438 VSS a_41852_148519# ESD_RAIL VSS nfet_06v0 ad=13.936p pd=54.12u as=13.936p ps=54.12u w=53.6u l=0.7u
X439 VSS a_42245_90628# ESD_RAIL VSS nfet_06v0 ad=13p pd=50.52u as=13p ps=50.52u w=50u l=0.7u
X440 VSS a_41852_148519# ESD_RAIL VSS nfet_06v0 ad=23.584p pd=0.10808m as=13.936p ps=54.12u w=53.6u l=0.7u
X441 VDD FS_NB_GATE FS_N_WELL FS_N_WELL pfet_06v0 ad=6.16p pd=28.88u as=6.16p ps=28.88u w=14u l=0.55u
X442 FS_N_OUT FS_N_GATE FS_N_WELL FS_N_WELL pfet_03v3 ad=6.16p pd=28.88u as=6.16p ps=28.88u w=14u l=0.28u
X443 TERM_N_R TERM_GATE_N TERM_VCM VSS nfet_06v0 ad=8.8p pd=40.88u as=8.8p ps=40.88u w=20u l=0.7u
X444 FS_P_OUT FS_PB_GATE FS_P_WELL FS_P_WELL pfet_03v3 ad=6.16p pd=28.88u as=6.16p ps=28.88u w=14u l=0.28u
X445 VSS a_41852_148519# ESD_RAIL VSS nfet_06v0 ad=13.936p pd=54.12u as=13.936p ps=54.12u w=53.6u l=0.7u
X446 VSS a_43813_117064# a_44789_117064# VSS nfet_06v0 ad=1.3p pd=5.52u as=1.3p ps=5.52u w=5u l=0.7u
X447 TERM_OR_P_PLS LS_SLOW VDD VDD pfet_03v3 ad=7.04p pd=32.88u as=7.04p ps=32.88u w=16u l=0.28u
X448 PULLUP_N_WELL PULLUP_N_BLEED_0 VSS ppolyf_u_1k r_width=1u r_length=12.5u
X449 ESD_RAIL a_41852_148519# VSS VSS nfet_06v0 ad=13.936p pd=54.12u as=13.936p ps=54.12u w=53.6u l=0.7u
X450 VDD FS_N_GATE FS_N_WELL FS_N_WELL pfet_06v0 ad=6.16p pd=28.88u as=6.16p ps=28.88u w=14u l=0.55u
X451 ESD_RAIL a_41852_148519# VSS VSS nfet_06v0 ad=13.936p pd=54.12u as=13.936p ps=54.12u w=53.6u l=0.7u
X452 TERM_GATE_N_BLEED_1 TERM_GATE_N_BLEED_2 VSS ppolyf_u_1k r_width=1u r_length=12.5u
X453 ESD_RAIL a_42245_90628# VSS VSS nfet_06v0 ad=22p pd=0.10088m as=13p ps=50.52u w=50u l=0.7u
D18 PAD_N ESD_RAIL diode_pd2nw_06v0 pj=51.8u area=22.5p
X454 HS_N_1 HS_N PAD_N VSS nfet_06v0 ad=8.8p pd=40.88u as=8.8p ps=40.88u w=20u l=0.7u
X455 VSS a_41852_148519# ESD_RAIL VSS nfet_06v0 ad=13.936p pd=54.12u as=13.936p ps=54.12u w=53.6u l=0.7u
X456 VSS a_42245_90628# ESD_RAIL VSS nfet_06v0 ad=13p pd=50.52u as=13p ps=50.52u w=50u l=0.7u
X457 TERM_LSA_GATE_P VSS VSS ppolyf_u_1k r_width=1u r_length=12.5u
X458 ESD_RAIL a_41852_148519# VSS VSS nfet_06v0 ad=13.936p pd=54.12u as=23.584p ps=0.10808m w=53.6u l=0.7u
X459 PULLUP_N_BLEED_1 PULLUP_N_BLEED_2 VSS ppolyf_u_1k r_width=1u r_length=12.5u
X460 VDD PULLUP_N_GATE PULLUP_N_WELL PULLUP_N_WELL pfet_06v0 ad=8.8p pd=40.88u as=8.8p ps=40.88u w=20u l=0.55u
X461 FS_N_OUT FS_N_GATE FS_N_WELL FS_N_WELL pfet_03v3 ad=6.16p pd=28.88u as=6.16p ps=28.88u w=14u l=0.28u
D19 VSS PAD_P diode_nd2ps_06v0 pj=51.8u area=22.5p
X462 VSS a_44789_117064# a_42245_90628# VSS nfet_06v0 ad=1.3p pd=5.52u as=1.3p ps=5.52u w=5u l=0.7u
X463 TERM_OR_P_B FS_LOW_P TERM_OR_P_NS VSS nfet_03v3 ad=1.3904p pd=7.2u as=1.3904p ps=7.2u w=3.16u l=0.28u
X464 ESD_RAIL a_41852_148519# VSS VSS nfet_06v0 ad=13.936p pd=54.12u as=13.936p ps=54.12u w=53.6u l=0.7u
X465 ESD_RAIL a_41852_148519# VSS VSS nfet_06v0 ad=13.936p pd=54.12u as=13.936p ps=54.12u w=53.6u l=0.7u
X466 HS_N_1 HS_PBIAS VDD VDD pfet_03v3 ad=8.8p pd=40.88u as=8.8p ps=40.88u w=20u l=1u
X467 VSS a_44789_117064# a_42245_90628# VSS nfet_06v0 ad=1.3p pd=5.52u as=1.3p ps=5.52u w=5u l=0.7u
X468 VDD FS_N_GATE FS_N_WELL FS_N_WELL pfet_06v0 ad=6.16p pd=28.88u as=6.16p ps=28.88u w=14u l=0.55u
X469 VSS a_41852_148519# ESD_RAIL VSS nfet_06v0 ad=13.936p pd=54.12u as=13.936p ps=54.12u w=53.6u l=0.7u
X470 VSS a_41852_148519# ESD_RAIL VSS nfet_06v0 ad=13.936p pd=54.12u as=13.936p ps=54.12u w=53.6u l=0.7u
X471 ESD_RAIL a_44789_117064# a_42245_90628# ESD_RAIL pfet_06v0 ad=1.3p pd=5.52u as=1.3p ps=5.52u w=5u l=0.7u
X472 VSS a_41852_148519# ESD_RAIL VSS nfet_06v0 ad=23.584p pd=0.10808m as=13.936p ps=54.12u w=53.6u l=0.7u
X473 ESD_RAIL a_41852_148519# cap_mim_2f0_m4m5_noshield c_width=90u c_length=90u
X474 FS_P_OUT FS_PB_GATE FS_P_WELL FS_P_WELL pfet_03v3 ad=6.16p pd=28.88u as=6.16p ps=28.88u w=14u l=0.28u
X475 TERM_P_R TERM_GATE_P TERM_VCM VSS nfet_06v0 ad=8.8p pd=40.88u as=8.8p ps=40.88u w=20u l=0.7u
X476 ESD_RAIL a_41852_148519# VSS VSS nfet_06v0 ad=13.936p pd=54.12u as=13.936p ps=54.12u w=53.6u l=0.7u
X477 VDD FS_N_GATE FS_N_WELL FS_N_WELL pfet_06v0 ad=6.16p pd=28.88u as=6.16p ps=28.88u w=14u l=0.55u
X478 a_41005_131545# a_53878_131545# ESD_RAIL ppolyf_u r_width=0.8u r_length=63.855u
X479 HS_N_3 HS_PBIAS VDD VDD pfet_03v3 ad=8.8p pd=40.88u as=8.8p ps=40.88u w=20u l=1u
X480 HS_P_11 HS_PBIAS VDD VDD pfet_03v3 ad=8.8p pd=40.88u as=8.8p ps=40.88u w=20u l=1u
X481 VSS a_42245_90628# ESD_RAIL VSS nfet_06v0 ad=13p pd=50.52u as=13p ps=50.52u w=50u l=0.7u
X482 HS_N_10 HS_N PAD_N VSS nfet_06v0 ad=8.8p pd=40.88u as=8.8p ps=40.88u w=20u l=0.7u
X483 TERM_N_R TERM_GATE_N TERM_VCM VSS nfet_06v0 ad=8.8p pd=40.88u as=8.8p ps=40.88u w=20u l=0.7u
X484 PAD_N BYPASS_ENABLE RX_N VSS nfet_06v0 ad=8.8p pd=40.88u as=8.8p ps=40.88u w=20u l=0.7u
X485 FS_N_OUT FS_N_GATE FS_N_WELL FS_N_WELL pfet_03v3 ad=6.16p pd=28.88u as=6.16p ps=28.88u w=14u l=0.28u
X486 PULLUP_P_BLEED_3 PULLUP_P_BLEED_4 VSS ppolyf_u_1k r_width=1u r_length=12.5u
X487 ESD_RAIL a_42245_90628# VSS VSS nfet_06v0 ad=13p pd=50.52u as=13p ps=50.52u w=50u l=0.7u
D20 PAD_N ESD_RAIL diode_pd2nw_06v0 pj=51.8u area=22.5p
X488 a_44789_117064# a_43813_117064# VSS VSS nfet_06v0 ad=1.3p pd=5.52u as=1.3p ps=5.52u w=5u l=0.7u
X489 ESD_RAIL a_42245_90628# VSS VSS nfet_06v0 ad=13p pd=50.52u as=13p ps=50.52u w=50u l=0.7u
X490 HS_N_3 HS_N PAD_N VSS nfet_06v0 ad=8.8p pd=40.88u as=8.8p ps=40.88u w=20u l=0.7u
X491 ESD_RAIL a_41852_148519# VSS VSS nfet_06v0 ad=13.936p pd=54.12u as=13.936p ps=54.12u w=53.6u l=0.7u
X492 ESD_RAIL a_41852_148519# VSS VSS nfet_06v0 ad=13.936p pd=54.12u as=13.936p ps=54.12u w=53.6u l=0.7u
X493 FS_N_OUT FS_N_GATE FS_N_WELL FS_N_WELL pfet_03v3 ad=6.16p pd=28.88u as=6.16p ps=28.88u w=14u l=0.28u
X494 FS_P_OUT FS_P_GATE FS_P_WELL FS_P_WELL pfet_03v3 ad=6.16p pd=28.88u as=6.16p ps=28.88u w=14u l=0.28u
X495 VSS a_42245_90628# ESD_RAIL VSS nfet_06v0 ad=13p pd=50.52u as=13p ps=50.52u w=50u l=0.7u
X496 VSS a_41852_148519# ESD_RAIL VSS nfet_06v0 ad=13.936p pd=54.12u as=13.936p ps=54.12u w=53.6u l=0.7u
X497 PULLUP_N_CONTROL_S VDD VSS VSS nfet_06v0 ad=1.76p pd=8.88u as=1.76p ps=8.88u w=4u l=0.7u
X498 FS_NB_BLEED_4 FS_NB_BLEED_5 VSS ppolyf_u_1k r_width=1u r_length=12.5u
X499 VSS a_41852_148519# ESD_RAIL VSS nfet_06v0 ad=13.936p pd=54.12u as=13.936p ps=54.12u w=53.6u l=0.7u
X500 VDD FS_N_GATE FS_N_WELL FS_N_WELL pfet_06v0 ad=6.16p pd=28.88u as=6.16p ps=28.88u w=14u l=0.55u
X501 VSS a_41852_148519# ESD_RAIL VSS nfet_06v0 ad=13.936p pd=54.12u as=13.936p ps=54.12u w=53.6u l=0.7u
X502 ESD_RAIL a_41852_148519# VSS VSS nfet_06v0 ad=13.936p pd=54.12u as=13.936p ps=54.12u w=53.6u l=0.7u
X503 FS_N_BLEED_3 FS_N_BLEED_4 VSS ppolyf_u_1k r_width=1u r_length=12.5u
X504 TERM_P_R TERM_GATE_P TERM_VCM VSS nfet_06v0 ad=8.8p pd=40.88u as=8.8p ps=40.88u w=20u l=0.7u
X505 ESD_RAIL a_41852_148519# VSS VSS nfet_06v0 ad=13.936p pd=54.12u as=13.936p ps=54.12u w=53.6u l=0.7u
X506 FS_NB_BLEED_6 FS_NB_GATE VSS ppolyf_u_1k r_width=1u r_length=12.5u
X507 FS_P_GATE VDD FS_P_WELL FS_P_WELL pfet_06v0 ad=1.76p pd=8.88u as=1.76p ps=8.88u w=4u l=0.55u
X508 a_41005_132385# a_53878_132665# ESD_RAIL ppolyf_u r_width=0.8u r_length=63.855u
X509 FS_N_BLEED_5 FS_N_BLEED_6 VSS ppolyf_u_1k r_width=1u r_length=12.5u
D21 PAD_N ESD_RAIL diode_pd2nw_06v0 pj=51.8u area=22.5p
X510 VSS a_41852_148519# ESD_RAIL VSS nfet_06v0 ad=13.936p pd=54.12u as=13.936p ps=54.12u w=53.6u l=0.7u
X511 ESD_RAIL a_41852_148519# VSS VSS nfet_06v0 ad=13.936p pd=54.12u as=13.936p ps=54.12u w=53.6u l=0.7u
X512 VSS a_41852_148519# ESD_RAIL VSS nfet_06v0 ad=13.936p pd=54.12u as=13.936p ps=54.12u w=53.6u l=0.7u
X513 TERM_P_R DIFF_ENABLE TERM_N_R VSS nfet_06v0 ad=8.8p pd=40.88u as=8.8p ps=40.88u w=20u l=0.7u
X514 FS_P_OUT FS_PB_GATE FS_P_WELL FS_P_WELL pfet_03v3 ad=6.16p pd=28.88u as=6.16p ps=28.88u w=14u l=0.28u
X515 VSS a_42245_90628# ESD_RAIL VSS nfet_06v0 ad=13p pd=50.52u as=13p ps=50.52u w=50u l=0.7u
X516 VSS a_41852_148519# ESD_RAIL VSS nfet_06v0 ad=13.936p pd=54.12u as=13.936p ps=54.12u w=53.6u l=0.7u
X517 FS_PB_BLEED_2 FS_PB_BLEED_3 VSS ppolyf_u_1k r_width=1u r_length=12.5u
X518 FS_P_OUT FS_P_GATE FS_P_WELL FS_P_WELL pfet_03v3 ad=6.16p pd=28.88u as=6.16p ps=28.88u w=14u l=0.28u
X519 ESD_RAIL a_41852_148519# VSS VSS nfet_06v0 ad=13.936p pd=54.12u as=13.936p ps=54.12u w=53.6u l=0.7u
X520 VSS a_42245_90628# ESD_RAIL VSS nfet_06v0 ad=13p pd=50.52u as=13p ps=50.52u w=50u l=0.7u
X521 ESD_RAIL a_41852_148519# VSS VSS nfet_06v0 ad=13.936p pd=54.12u as=13.936p ps=54.12u w=53.6u l=0.7u
X522 VDD FS_NB_GATE FS_N_WELL FS_N_WELL pfet_06v0 ad=6.16p pd=28.88u as=6.16p ps=28.88u w=14u l=0.55u
X523 FS_P_BLEED_1 FS_P_BLEED_2 VSS ppolyf_u_1k r_width=1u r_length=12.5u
X524 FS_NB_BLEED_0 FS_NB_BLEED_1 VSS ppolyf_u_1k r_width=1u r_length=12.5u
X525 ESD_RAIL a_42245_90628# VSS VSS nfet_06v0 ad=13p pd=50.52u as=13p ps=50.52u w=50u l=0.7u
X526 ESD_RAIL a_41852_148519# VSS VSS nfet_06v0 ad=13.936p pd=54.12u as=23.584p ps=0.10808m w=53.6u l=0.7u
X527 ESD_RAIL a_41852_148519# VSS VSS nfet_06v0 ad=13.936p pd=54.12u as=13.936p ps=54.12u w=53.6u l=0.7u
X528 VDD FS_NB_GATE FS_N_WELL FS_N_WELL pfet_06v0 ad=6.16p pd=28.88u as=6.16p ps=28.88u w=14u l=0.55u
X529 FS_N_WELL FS_N_BLEED_0 VSS ppolyf_u_1k r_width=1u r_length=12.5u
X530 TERM_OR_N_B FS_LOW_N TERM_OR_N_S VDD pfet_03v3 ad=2.7808p pd=13.52u as=2.7808p ps=13.52u w=6.32u l=0.28u
X531 HS_P_0 HS_P PAD_P VSS nfet_06v0 ad=8.8p pd=40.88u as=8.8p ps=40.88u w=20u l=0.7u
X532 ESD_RAIL a_41852_148519# VSS VSS nfet_06v0 ad=13.936p pd=54.12u as=13.936p ps=54.12u w=53.6u l=0.7u
D22 PAD_N ESD_RAIL diode_pd2nw_06v0 pj=51.8u area=22.5p
X533 TERM_OR_P_NS VCM_LOW_OK VSS VSS nfet_03v3 ad=2.7808p pd=13.52u as=2.7808p ps=13.52u w=6.32u l=0.28u
X534 PAD_P BYPASS_ENABLE RX_P VSS nfet_06v0 ad=8.8p pd=40.88u as=8.8p ps=40.88u w=20u l=0.7u
X535 VSS a_41852_148519# ESD_RAIL VSS nfet_06v0 ad=13.936p pd=54.12u as=13.936p ps=54.12u w=53.6u l=0.7u
X536 a_41005_133505# a_53878_133785# ESD_RAIL ppolyf_u r_width=0.8u r_length=63.855u
X537 TERM_P_R DIFF_ENABLE TERM_N_R VSS nfet_06v0 ad=8.8p pd=40.88u as=8.8p ps=40.88u w=20u l=0.7u
X538 VSS a_41852_148519# ESD_RAIL VSS nfet_06v0 ad=13.936p pd=54.12u as=13.936p ps=54.12u w=53.6u l=0.7u
X539 FS_PB_BLEED_0 FS_PB_BLEED_1 VSS ppolyf_u_1k r_width=1u r_length=12.5u
X540 ESD_RAIL a_41852_148519# VSS VSS nfet_06v0 ad=13.936p pd=54.12u as=13.936p ps=54.12u w=53.6u l=0.7u
X541 ESD_RAIL a_42245_90628# VSS VSS nfet_06v0 ad=13p pd=50.52u as=13p ps=50.52u w=50u l=0.7u
X542 PAD_P BYPASS_ENABLE RX_P VSS nfet_06v0 ad=8.8p pd=40.88u as=8.8p ps=40.88u w=20u l=0.7u
X543 FS_N_CONTROL_S VDD VSS VSS nfet_06v0 ad=7.04p pd=32.88u as=7.04p ps=32.88u w=16u l=0.7u
X544 HS_P_1 HS_PBIAS VDD VDD pfet_03v3 ad=8.8p pd=40.88u as=8.8p ps=40.88u w=20u l=1u
X545 FS_P_WELL FS_P_BLEED_0 VSS ppolyf_u_1k r_width=1u r_length=12.5u
X546 ESD_RAIL a_42245_90628# VSS VSS nfet_06v0 ad=13p pd=50.52u as=13p ps=50.52u w=50u l=0.7u
X547 VSS a_42245_90628# ESD_RAIL VSS nfet_06v0 ad=13p pd=50.52u as=13p ps=50.52u w=50u l=0.7u
X548 VSS a_41852_148519# ESD_RAIL VSS nfet_06v0 ad=13.936p pd=54.12u as=13.936p ps=54.12u w=53.6u l=0.7u
X549 ESD_RAIL a_44789_117064# a_42245_90628# ESD_RAIL pfet_06v0 ad=1.3p pd=5.52u as=1.3p ps=5.52u w=5u l=0.7u
X550 VSS a_41852_148519# ESD_RAIL VSS nfet_06v0 ad=13.936p pd=54.12u as=13.936p ps=54.12u w=53.6u l=0.7u
X551 VSS a_41852_148519# ESD_RAIL VSS nfet_06v0 ad=13.936p pd=54.12u as=13.936p ps=54.12u w=53.6u l=0.7u
X552 VSS a_42245_90628# ESD_RAIL VSS nfet_06v0 ad=13p pd=50.52u as=13p ps=50.52u w=50u l=0.7u
X553 PAD_N TERM_N_R VSS ppolyf_u r_width=16u r_length=1.48u
X554 TERM_GATE_N TERM_OR_N_B VSS VSS nfet_03v3 ad=4.4p pd=20.88u as=4.4p ps=20.88u w=10u l=0.28u
X555 ESD_RAIL a_41852_148519# VSS VSS nfet_06v0 ad=13.936p pd=54.12u as=13.936p ps=54.12u w=53.6u l=0.7u
X556 FS_NB_GATE VDD FS_N_WELL FS_N_WELL pfet_06v0 ad=1.76p pd=8.88u as=1.76p ps=8.88u w=4u l=0.55u
X557 FS_P_OUT FS_P_GATE FS_P_WELL FS_P_WELL pfet_03v3 ad=6.16p pd=28.88u as=6.16p ps=28.88u w=14u l=0.28u
X558 VSS a_41852_148519# ESD_RAIL VSS nfet_06v0 ad=13.936p pd=54.12u as=13.936p ps=54.12u w=53.6u l=0.7u
X559 HS_P_8 HS_P PAD_P VSS nfet_06v0 ad=8.8p pd=40.88u as=8.8p ps=40.88u w=20u l=0.7u
X560 a_44789_117064# a_43813_117064# VSS VSS nfet_06v0 ad=1.3p pd=5.52u as=1.3p ps=5.52u w=5u l=0.7u
X561 VSS a_41852_148519# ESD_RAIL VSS nfet_06v0 ad=13.936p pd=54.12u as=13.936p ps=54.12u w=53.6u l=0.7u
X562 ESD_RAIL a_41852_148519# VSS VSS nfet_06v0 ad=13.936p pd=54.12u as=23.584p ps=0.10808m w=53.6u l=0.7u
X563 ESD_RAIL a_41852_148519# VSS VSS nfet_06v0 ad=13.936p pd=54.12u as=23.584p ps=0.10808m w=53.6u l=0.7u
X564 ESD_RAIL a_41852_148519# VSS VSS nfet_06v0 ad=13.936p pd=54.12u as=13.936p ps=54.12u w=53.6u l=0.7u
X565 VDD FS_N_GATE FS_N_WELL FS_N_WELL pfet_06v0 ad=6.16p pd=28.88u as=6.16p ps=28.88u w=14u l=0.55u
X566 TERM_P_R TERM_GATE_P TERM_VCM VSS nfet_06v0 ad=8.8p pd=40.88u as=8.8p ps=40.88u w=20u l=0.7u
D23 VSS ESD_RAIL diode_nd2ps_06v0 pj=82u area=40p
X567 VSS a_41852_148519# ESD_RAIL VSS nfet_06v0 ad=13.936p pd=54.12u as=13.936p ps=54.12u w=53.6u l=0.7u
X568 VSS a_41852_148519# ESD_RAIL VSS nfet_06v0 ad=23.584p pd=0.10808m as=13.936p ps=54.12u w=53.6u l=0.7u
X569 PULLUP_P_WELL PULLUP_P_BLEED_0 VSS ppolyf_u_1k r_width=1u r_length=12.5u
X570 VSS a_42245_90628# ESD_RAIL VSS nfet_06v0 ad=13p pd=50.52u as=13p ps=50.52u w=50u l=0.7u
X571 VSS a_42245_90628# ESD_RAIL VSS nfet_06v0 ad=13p pd=50.52u as=13p ps=50.52u w=50u l=0.7u
X572 ESD_RAIL a_41852_148519# VSS VSS nfet_06v0 ad=13.936p pd=54.12u as=13.936p ps=54.12u w=53.6u l=0.7u
X573 VSS a_42245_90628# ESD_RAIL VSS nfet_06v0 ad=13p pd=50.52u as=13p ps=50.52u w=50u l=0.7u
X574 a_42245_90628# VSS VSS ppolyf_u_1k_6p0 r_width=1u r_length=99.24u
X575 TERM_GATE_P_BLEED_1 TERM_GATE_P_BLEED_2 VSS ppolyf_u_1k r_width=1u r_length=12.5u
X576 VDD FS_PB_GATE FS_P_WELL FS_P_WELL pfet_06v0 ad=6.16p pd=28.88u as=6.16p ps=28.88u w=14u l=0.55u
X577 VSS a_42245_90628# ESD_RAIL VSS nfet_06v0 ad=13p pd=50.52u as=13p ps=50.52u w=50u l=0.7u
X578 ESD_RAIL a_42245_90628# VSS VSS nfet_06v0 ad=13p pd=50.52u as=13p ps=50.52u w=50u l=0.7u
X579 VCM_LOW_OK TERM_VCM VDD VDD pfet_03v3 ad=0.88p pd=4.88u as=0.88p ps=4.88u w=2u l=0.28u
X580 PULLUP_N_BLEED_4 PULLUP_N_BLEED_5 VSS ppolyf_u_1k r_width=1u r_length=12.5u
X581 HS_P_7 HS_P PAD_P VSS nfet_06v0 ad=8.8p pd=40.88u as=8.8p ps=40.88u w=20u l=0.7u
X582 PAD_N TRIM_N_0_R VSS ppolyf_u r_width=4u r_length=2.4u
X583 ESD_RAIL a_41852_148519# VSS VSS nfet_06v0 ad=13.936p pd=54.12u as=13.936p ps=54.12u w=53.6u l=0.7u
X584 VSS a_41852_148519# ESD_RAIL VSS nfet_06v0 ad=13.936p pd=54.12u as=13.936p ps=54.12u w=53.6u l=0.7u
X585 VCM_LOW_OK TERM_VCM VSS VSS nfet_03v3 ad=3.52p pd=16.88u as=3.52p ps=16.88u w=8u l=0.28u
X586 DIV_LOW_P DIV_ENABLE VSS VSS nfet_06v0 ad=8.8p pd=40.88u as=8.8p ps=40.88u w=20u l=0.7u
X587 ESD_RAIL a_42245_90628# VSS VSS nfet_06v0 ad=22p pd=0.10088m as=13p ps=50.52u w=50u l=0.7u
X588 a_41005_133505# a_53878_133225# ESD_RAIL ppolyf_u r_width=0.8u r_length=63.855u
X589 ESD_RAIL a_41852_148519# VSS VSS nfet_06v0 ad=13.936p pd=54.12u as=13.936p ps=54.12u w=53.6u l=0.7u
X590 TERM_P_R TERM_LSA_GATE_P TERM_VCM VSS nfet_06v0 ad=8.8p pd=40.88u as=8.8p ps=40.88u w=20u l=0.7u
X591 VDD FS_PB_GATE FS_P_WELL FS_P_WELL pfet_06v0 ad=6.16p pd=28.88u as=6.16p ps=28.88u w=14u l=0.55u
X592 TERM_GATE_P TERM_OR_P_B TERM_OR_P_PLS VDD pfet_03v3 ad=7.04p pd=32.88u as=7.04p ps=32.88u w=16u l=0.28u
D24 VSS FS_LOW_N diode_nd2ps_03v3 pj=5.32u area=1.7689p
X593 VDD FS_PB_GATE FS_P_WELL FS_P_WELL pfet_06v0 ad=6.16p pd=28.88u as=6.16p ps=28.88u w=14u l=0.55u
X594 VSS a_41852_148519# ESD_RAIL VSS nfet_06v0 ad=23.584p pd=0.10808m as=13.936p ps=54.12u w=53.6u l=0.7u
X595 VDD FS_PB_GATE FS_P_WELL FS_P_WELL pfet_06v0 ad=6.16p pd=28.88u as=6.16p ps=28.88u w=14u l=0.55u
X596 HS_P_1 HS_P PAD_P VSS nfet_06v0 ad=8.8p pd=40.88u as=8.8p ps=40.88u w=20u l=0.7u
X597 VDD FS_PB_GATE FS_P_WELL FS_P_WELL pfet_06v0 ad=6.16p pd=28.88u as=6.16p ps=28.88u w=14u l=0.55u
X598 HS_P_4 HS_P PAD_P VSS nfet_06v0 ad=8.8p pd=40.88u as=8.8p ps=40.88u w=20u l=0.7u
X599 VSS a_41852_148519# ESD_RAIL VSS nfet_06v0 ad=13.936p pd=54.12u as=13.936p ps=54.12u w=53.6u l=0.7u
X600 VSS a_42245_90628# ESD_RAIL VSS nfet_06v0 ad=13p pd=50.52u as=13p ps=50.52u w=50u l=0.7u
X601 ESD_RAIL a_41852_148519# VSS VSS nfet_06v0 ad=13.936p pd=54.12u as=13.936p ps=54.12u w=53.6u l=0.7u
X602 TERM_OR_N_B TERM_ENABLE VSS VSS nfet_03v3 ad=1.3904p pd=7.2u as=1.3904p ps=7.2u w=3.16u l=0.28u
X603 ESD_RAIL a_41852_148519# VSS VSS nfet_06v0 ad=13.936p pd=54.12u as=13.936p ps=54.12u w=53.6u l=0.7u
X604 FS_PB_BLEED_4 FS_PB_BLEED_5 VSS ppolyf_u_1k r_width=1u r_length=12.5u
X605 ESD_RAIL a_44789_117064# a_42245_90628# ESD_RAIL pfet_06v0 ad=1.3p pd=5.52u as=1.3p ps=5.52u w=5u l=0.7u
X606 VSS a_41852_148519# ESD_RAIL VSS nfet_06v0 ad=13.936p pd=54.12u as=13.936p ps=54.12u w=53.6u l=0.7u
X607 ESD_RAIL a_42245_90628# VSS VSS nfet_06v0 ad=13p pd=50.52u as=13p ps=50.52u w=50u l=0.7u
X608 PULLUP_N_OUT PULLUP_N_GATE PULLUP_N_WELL PULLUP_N_WELL pfet_03v3 ad=8.8p pd=40.88u as=8.8p ps=40.88u w=20u l=0.28u
X609 FS_P_BLEED_3 FS_P_BLEED_4 VSS ppolyf_u_1k r_width=1u r_length=12.5u
X610 HS_P_12 HS_PBIAS VDD VDD pfet_03v3 ad=8.8p pd=40.88u as=8.8p ps=40.88u w=20u l=1u
X611 ESD_RAIL a_53878_134345# ESD_RAIL ppolyf_u r_width=0.8u r_length=63.855u
X612 ESD_RAIL a_41852_148519# VSS VSS nfet_06v0 ad=13.936p pd=54.12u as=13.936p ps=54.12u w=53.6u l=0.7u
D25 VSS PAD_N diode_nd2ps_06v0 pj=51.8u area=22.5p
X613 VDD FS_PB_GATE FS_P_WELL FS_P_WELL pfet_06v0 ad=6.16p pd=28.88u as=6.16p ps=28.88u w=14u l=0.55u
D26 PAD_P ESD_RAIL diode_pd2nw_06v0 pj=51.8u area=22.5p
X614 HS_P_13 HS_P PAD_P VSS nfet_06v0 ad=8.8p pd=40.88u as=8.8p ps=40.88u w=20u l=0.7u
X615 ESD_RAIL a_41852_148519# VSS VSS nfet_06v0 ad=13.936p pd=54.12u as=13.936p ps=54.12u w=53.6u l=0.7u
X616 ESD_RAIL a_41852_148519# VSS VSS nfet_06v0 ad=13.936p pd=54.12u as=13.936p ps=54.12u w=53.6u l=0.7u
X617 HS_N_10 HS_PBIAS VDD VDD pfet_03v3 ad=8.8p pd=40.88u as=8.8p ps=40.88u w=20u l=1u
X618 PULLUP_P_BLEED_4 PULLUP_P_BLEED_5 VSS ppolyf_u_1k r_width=1u r_length=12.5u
X619 VDD FS_P_GATE FS_P_WELL FS_P_WELL pfet_06v0 ad=6.16p pd=28.88u as=6.16p ps=28.88u w=14u l=0.55u
X620 ESD_RAIL a_41852_148519# VSS VSS nfet_06v0 ad=13.936p pd=54.12u as=13.936p ps=54.12u w=53.6u l=0.7u
X621 VSS a_41852_148519# ESD_RAIL VSS nfet_06v0 ad=13.936p pd=54.12u as=13.936p ps=54.12u w=53.6u l=0.7u
X622 ESD_RAIL a_41852_148519# VSS VSS nfet_06v0 ad=13.936p pd=54.12u as=13.936p ps=54.12u w=53.6u l=0.7u
X623 TERM_OR_P_B TERM_ENABLE VSS VSS nfet_03v3 ad=1.3904p pd=7.2u as=1.3904p ps=7.2u w=3.16u l=0.28u
X624 HS_N_0 HS_PBIAS VDD VDD pfet_03v3 ad=8.8p pd=40.88u as=8.8p ps=40.88u w=20u l=1u
X625 VDD FS_P_GATE FS_P_WELL FS_P_WELL pfet_06v0 ad=6.16p pd=28.88u as=6.16p ps=28.88u w=14u l=0.55u
X626 VSS a_41852_148519# ESD_RAIL VSS nfet_06v0 ad=13.936p pd=54.12u as=13.936p ps=54.12u w=53.6u l=0.7u
X627 VSS a_42245_90628# ESD_RAIL VSS nfet_06v0 ad=13p pd=50.52u as=22p ps=0.10088m w=50u l=0.7u
X628 VSS a_41852_148519# ESD_RAIL VSS nfet_06v0 ad=23.584p pd=0.10808m as=13.936p ps=54.12u w=53.6u l=0.7u
X629 VSS a_41852_148519# ESD_RAIL VSS nfet_06v0 ad=13.936p pd=54.12u as=13.936p ps=54.12u w=53.6u l=0.7u
X630 VSS a_41852_148519# ESD_RAIL VSS nfet_06v0 ad=13.936p pd=54.12u as=13.936p ps=54.12u w=53.6u l=0.7u
X631 PULLUP_N_OUT PULLUP_N_GATE PULLUP_N_WELL PULLUP_N_WELL pfet_03v3 ad=8.8p pd=40.88u as=8.8p ps=40.88u w=20u l=0.28u
X632 VSS a_41852_148519# ESD_RAIL VSS nfet_06v0 ad=13.936p pd=54.12u as=13.936p ps=54.12u w=53.6u l=0.7u
X633 VSS a_42245_90628# ESD_RAIL VSS nfet_06v0 ad=13p pd=50.52u as=13p ps=50.52u w=50u l=0.7u
X634 ESD_RAIL a_42245_90628# VSS VSS nfet_06v0 ad=13p pd=50.52u as=13p ps=50.52u w=50u l=0.7u
X635 HS_N_12 HS_N PAD_N VSS nfet_06v0 ad=8.8p pd=40.88u as=8.8p ps=40.88u w=20u l=0.7u
X636 HS_N_2 HS_PBIAS VDD VDD pfet_03v3 ad=8.8p pd=40.88u as=8.8p ps=40.88u w=20u l=1u
X637 VDD FS_P_GATE FS_P_WELL FS_P_WELL pfet_06v0 ad=6.16p pd=28.88u as=6.16p ps=28.88u w=14u l=0.55u
X638 HS_P_10 HS_PBIAS VDD VDD pfet_03v3 ad=8.8p pd=40.88u as=8.8p ps=40.88u w=20u l=1u
X639 ESD_RAIL a_42245_90628# VSS VSS nfet_06v0 ad=13p pd=50.52u as=13p ps=50.52u w=50u l=0.7u
D27 VSS PAD_P diode_nd2ps_06v0 pj=51.8u area=22.5p
X640 TERM_N_R TERM_GATE_N TERM_VCM VSS nfet_06v0 ad=8.8p pd=40.88u as=8.8p ps=40.88u w=20u l=0.7u
X641 PAD_N BYPASS_ENABLE RX_N VSS nfet_06v0 ad=8.8p pd=40.88u as=8.8p ps=40.88u w=20u l=0.7u
X642 ESD_RAIL a_42245_90628# VSS VSS nfet_06v0 ad=13p pd=50.52u as=13p ps=50.52u w=50u l=0.7u
X643 VSS a_41852_148519# ESD_RAIL VSS nfet_06v0 ad=13.936p pd=54.12u as=13.936p ps=54.12u w=53.6u l=0.7u
X644 PULLUP_P_BLEED_2 PULLUP_P_BLEED_3 VSS ppolyf_u_1k r_width=1u r_length=12.5u
X645 ESD_RAIL a_41852_148519# VSS VSS nfet_06v0 ad=13.936p pd=54.12u as=13.936p ps=54.12u w=53.6u l=0.7u
X646 VSS a_42245_90628# ESD_RAIL VSS nfet_06v0 ad=13p pd=50.52u as=13p ps=50.52u w=50u l=0.7u
X647 TERM_OR_P_B FS_LOW_P TERM_OR_P_S VDD pfet_03v3 ad=2.7808p pd=13.52u as=2.7808p ps=13.52u w=6.32u l=0.28u
X648 VSS a_41852_148519# ESD_RAIL VSS nfet_06v0 ad=13.936p pd=54.12u as=13.936p ps=54.12u w=53.6u l=0.7u
D28 VSS TERM_TRIM0 diode_nd2ps_03v3 pj=4.6u area=1.3225p
X649 TERM_LSA_GATE_N TERM_OR_N_B VDD VDD pfet_03v3 ad=3.52p pd=16.88u as=3.52p ps=16.88u w=8u l=0.28u
X650 ESD_RAIL a_41852_148519# VSS VSS nfet_06v0 ad=13.936p pd=54.12u as=13.936p ps=54.12u w=53.6u l=0.7u
X651 HS_P_9 HS_P PAD_P VSS nfet_06v0 ad=8.8p pd=40.88u as=8.8p ps=40.88u w=20u l=0.7u
X652 ESD_RAIL a_41852_148519# VSS VSS nfet_06v0 ad=13.936p pd=54.12u as=13.936p ps=54.12u w=53.6u l=0.7u
D29 PAD_P ESD_RAIL diode_pd2nw_06v0 pj=51.8u area=22.5p
X653 FS_N_OUT FS_NB_GATE FS_N_WELL FS_N_WELL pfet_03v3 ad=6.16p pd=28.88u as=6.16p ps=28.88u w=14u l=0.28u
X654 HS_P_4 HS_PBIAS VDD VDD pfet_03v3 ad=8.8p pd=40.88u as=8.8p ps=40.88u w=20u l=1u
X655 VSS a_41852_148519# ESD_RAIL VSS nfet_06v0 ad=13.936p pd=54.12u as=13.936p ps=54.12u w=53.6u l=0.7u
X656 VDD FS_P_GATE FS_P_WELL FS_P_WELL pfet_06v0 ad=6.16p pd=28.88u as=6.16p ps=28.88u w=14u l=0.55u
X657 ESD_RAIL a_41852_148519# VSS VSS nfet_06v0 ad=13.936p pd=54.12u as=13.936p ps=54.12u w=53.6u l=0.7u
X658 ESD_RAIL a_41852_148519# VSS VSS nfet_06v0 ad=13.936p pd=54.12u as=13.936p ps=54.12u w=53.6u l=0.7u
X659 ESD_RAIL a_41005_131545# a_43813_117064# ESD_RAIL pfet_06v0 ad=1.3p pd=5.52u as=1.3p ps=5.52u w=5u l=0.7u
X660 VSS a_41852_148519# ESD_RAIL VSS nfet_06v0 ad=13.936p pd=54.12u as=13.936p ps=54.12u w=53.6u l=0.7u
X661 PAD_P DIV_P VSS ppolyf_u_1k r_width=1u r_length=2u
X662 FS_P_OUT PAD_P VSS ppolyf_s r_width=2u r_length=3.5u
X663 ESD_RAIL a_41852_148519# VSS VSS nfet_06v0 ad=13.936p pd=54.12u as=13.936p ps=54.12u w=53.6u l=0.7u
X664 VSS a_41852_148519# ESD_RAIL VSS nfet_06v0 ad=13.936p pd=54.12u as=13.936p ps=54.12u w=53.6u l=0.7u
X665 LS_SLOW_B LS_SLOW VSS VSS nfet_03v3 ad=0.88p pd=4.88u as=0.88p ps=4.88u w=2u l=0.28u
X666 PAD_N TRIM_N_1_R VSS ppolyf_u r_width=8u r_length=2.4u
X667 FS_NB_GATE FS_HIGH_N FS_NB_CONTROL_S VSS nfet_06v0 ad=3.52p pd=16.88u as=3.52p ps=16.88u w=8u l=0.7u
D30 VSS PAD_N diode_nd2ps_06v0 pj=51.8u area=22.5p
X668 VSS a_41852_148519# ESD_RAIL VSS nfet_06v0 ad=13.936p pd=54.12u as=13.936p ps=54.12u w=53.6u l=0.7u
X669 FS_N_GATE FS_HIGH_N FS_N_WELL FS_N_WELL pfet_06v0 ad=7.04p pd=32.88u as=7.04p ps=32.88u w=16u l=0.55u
X670 FS_N_WELL FS_NB_BLEED_0 VSS ppolyf_u_1k r_width=1u r_length=12.5u
X671 ESD_RAIL a_41852_148519# VSS VSS nfet_06v0 ad=13.936p pd=54.12u as=13.936p ps=54.12u w=53.6u l=0.7u
D31 VSS PAD_P diode_nd2ps_06v0 pj=51.8u area=22.5p
X672 a_42245_90628# a_44789_117064# ESD_RAIL ESD_RAIL pfet_06v0 ad=1.3p pd=5.52u as=1.3p ps=5.52u w=5u l=0.7u
X673 FS_P_BLEED_6 FS_P_GATE VSS ppolyf_u_1k r_width=1u r_length=12.5u
X674 HS_P_2 HS_P PAD_P VSS nfet_06v0 ad=8.8p pd=40.88u as=8.8p ps=40.88u w=20u l=0.7u
X675 VSS a_42245_90628# ESD_RAIL VSS nfet_06v0 ad=13p pd=50.52u as=13p ps=50.52u w=50u l=0.7u
X676 VSS a_41852_148519# ESD_RAIL VSS nfet_06v0 ad=23.584p pd=0.10808m as=13.936p ps=54.12u w=53.6u l=0.7u
X677 FS_N_GATE FS_HIGH_N FS_N_CONTROL_S VSS nfet_06v0 ad=3.52p pd=16.88u as=3.52p ps=16.88u w=8u l=0.7u
X678 ESD_RAIL a_42245_90628# VSS VSS nfet_06v0 ad=13p pd=50.52u as=13p ps=50.52u w=50u l=0.7u
X679 ESD_RAIL a_42245_90628# VSS VSS nfet_06v0 ad=13p pd=50.52u as=13p ps=50.52u w=50u l=0.7u
X680 VSS a_41852_148519# ESD_RAIL VSS nfet_06v0 ad=13.936p pd=54.12u as=13.936p ps=54.12u w=53.6u l=0.7u
X681 VSS a_41852_148519# ESD_RAIL VSS nfet_06v0 ad=13.936p pd=54.12u as=13.936p ps=54.12u w=53.6u l=0.7u
X682 VSS a_41852_148519# ESD_RAIL VSS nfet_06v0 ad=13.936p pd=54.12u as=13.936p ps=54.12u w=53.6u l=0.7u
X683 ESD_RAIL a_42245_90628# VSS VSS nfet_06v0 ad=13p pd=50.52u as=13p ps=50.52u w=50u l=0.7u
X684 VSS a_42245_90628# ESD_RAIL VSS nfet_06v0 ad=13p pd=50.52u as=13p ps=50.52u w=50u l=0.7u
X685 PULLDOWN_N_R PULLDOWN_N VSS VSS nfet_06v0 ad=3.52p pd=16.88u as=3.52p ps=16.88u w=8u l=0.7u
D32 PAD_P ESD_RAIL diode_pd2nw_06v0 pj=51.8u area=22.5p
X686 ESD_RAIL a_42245_90628# VSS VSS nfet_06v0 ad=13p pd=50.52u as=13p ps=50.52u w=50u l=0.7u
X687 a_42245_90628# a_44789_117064# ESD_RAIL ESD_RAIL pfet_06v0 ad=1.3p pd=5.52u as=1.3p ps=5.52u w=5u l=0.7u
X688 PULLUP_N_OUT PULLUP_N_GATE PULLUP_N_WELL PULLUP_N_WELL pfet_03v3 ad=8.8p pd=40.88u as=8.8p ps=40.88u w=20u l=0.28u
X689 TERM_GATE_P_BLEED_2 VSS VSS ppolyf_u_1k r_width=1u r_length=12.5u
X690 VSS a_41852_148519# ESD_RAIL VSS nfet_06v0 ad=23.584p pd=0.10808m as=13.936p ps=54.12u w=53.6u l=0.7u
X691 PULLUP_P_BLEED_6 PULLUP_P_GATE VSS ppolyf_u_1k r_width=1u r_length=12.5u
X692 ESD_RAIL a_41852_148519# VSS VSS nfet_06v0 ad=13.936p pd=54.12u as=13.936p ps=54.12u w=53.6u l=0.7u
X693 PULLUP_N_BLEED_5 PULLUP_N_BLEED_6 VSS ppolyf_u_1k r_width=1u r_length=12.5u
X694 PAD_P TRIM_P_1_R VSS ppolyf_u r_width=8u r_length=2.4u
X695 a_42245_90628# a_44789_117064# ESD_RAIL ESD_RAIL pfet_06v0 ad=1.3p pd=5.52u as=1.3p ps=5.52u w=5u l=0.7u
X696 HS_N_11 HS_N PAD_N VSS nfet_06v0 ad=8.8p pd=40.88u as=8.8p ps=40.88u w=20u l=0.7u
X697 ESD_RAIL a_41852_148519# VSS VSS nfet_06v0 ad=13.936p pd=54.12u as=13.936p ps=54.12u w=53.6u l=0.7u
X698 TERM_GATE_N_BLEED_0 TERM_GATE_N_BLEED_1 VSS ppolyf_u_1k r_width=1u r_length=12.5u
X699 VSS a_41852_148519# ESD_RAIL VSS nfet_06v0 ad=13.936p pd=54.12u as=13.936p ps=54.12u w=53.6u l=0.7u
X700 HS_N_0 HS_N PAD_N VSS nfet_06v0 ad=8.8p pd=40.88u as=8.8p ps=40.88u w=20u l=0.7u
X701 VSS a_41852_148519# ESD_RAIL VSS nfet_06v0 ad=13.936p pd=54.12u as=13.936p ps=54.12u w=53.6u l=0.7u
X702 ESD_RAIL a_44789_117064# a_42245_90628# ESD_RAIL pfet_06v0 ad=1.3p pd=5.52u as=1.3p ps=5.52u w=5u l=0.7u
X703 PAD_N BYPASS_ENABLE RX_N VSS nfet_06v0 ad=8.8p pd=40.88u as=8.8p ps=40.88u w=20u l=0.7u
X704 PAD_N BYPASS_ENABLE RX_N VSS nfet_06v0 ad=8.8p pd=40.88u as=8.8p ps=40.88u w=20u l=0.7u
X705 a_41005_132385# a_53878_132105# ESD_RAIL ppolyf_u r_width=0.8u r_length=63.855u
X706 ESD_RAIL a_41852_148519# VSS VSS nfet_06v0 ad=13.936p pd=54.12u as=13.936p ps=54.12u w=53.6u l=0.7u
X707 FS_N_OUT FS_NB_GATE FS_N_WELL FS_N_WELL pfet_03v3 ad=6.16p pd=28.88u as=6.16p ps=28.88u w=14u l=0.28u
X708 ESD_RAIL a_41852_148519# VSS VSS nfet_06v0 ad=13.936p pd=54.12u as=13.936p ps=54.12u w=53.6u l=0.7u
X709 FS_P_OUT FS_PB_GATE FS_P_WELL FS_P_WELL pfet_03v3 ad=6.16p pd=28.88u as=6.16p ps=28.88u w=14u l=0.28u
X710 ESD_RAIL a_41852_148519# VSS VSS nfet_06v0 ad=13.936p pd=54.12u as=13.936p ps=54.12u w=53.6u l=0.7u
C0 PULLUP_N_BLEED_3 HS_PBIAS 0.09588f
C1 HS_P TERM_TRIM0 0.05441f
C2 PULLUP_P_OUT HS_P_13 0.05276f
C3 TERM_TRIM2 TRIM_P_1_R 0.05252f
C4 HS_P_10 TERM_GATE_P 0.17038f
C5 TERM_ENABLE TRIM_P_0_R 0.04961f
C6 HS_N_8 TERM_GATE_N_BLEED_2 0.00108f
C7 HS_P_8 DIV_ENABLE 0.03996f
C8 HS_N TERM_GATE_N_BLEED_0 0.02215f
C9 HS_N_5 FS_P_OUT 0.7159f
C10 HS_P_1 HS_P_10 51.0309f
C11 LS_SLOW HS_PBIAS 0.93007f
C12 HS_PBIAS HS_P_5 3.67316f
C13 TERM_OR_P_S HS_P_6 0.02404f
C14 TERM_VCM TRIM_N_0_R 0.12887p
C15 PULLUP_N_GATE PULLUP_N_BLEED_1 1.58902f
C16 HS_N_8 FS_P_OUT 0.71639f
C17 HS_N_9 TERM_GATE_P 0.10908f
C18 FS_P_GATE HS_N_3 0.2337f
C19 TERM_P_R HS_N_12 0.09459f
C20 TERM_OR_P_S HS_N_3 0.02404f
C21 VCM_LOW_OK TERM_LSA_GATE_P 0.0716f
C22 HS_N_9 HS_P_1 0.06578f
C23 HS_P TERM_LSA_GATE_P 0.0716f
C24 FS_LOW_P HS_N_6 0.08963f
C25 HS_P_8 TRIM_P_0_R 0.04808f
C26 PULLUP_N_BLEED_6 PULLUP_N_BLEED_5 0.03602f
C27 FS_NB_BLEED_5 PULLUP_N_WELL 0
C28 VCM_LOW_OK TERM_GATE_P_BLEED_2 0.01215f
C29 PULLUP_P_OUT HS_PBIAS 0.54819f
C30 HS_P_9 TERM_P_R 0.16148f
C31 PULLUP_P_BLEED_3 PULLUP_N_OUT 0
C32 RX_P FS_P_OUT 0.01238f
C33 LS_SLOW HS_P_11 0.08369f
C34 HS_P_11 HS_P_5 0
C35 HS_N_0 TERM_GATE_N_BLEED_1 0.04058f
C36 TERM_VCM HS_N_10 0.24047f
C37 HS_N_6 DIV_ENABLE 0.08392f
C38 DIV_N TERM_OR_P_B 0
C39 TERM_VCM FS_N_GATE 0.22131f
C40 DIV_P TRIM_P_1_R 0.04134f
C41 TRIM_N_0_R TRIM_N_2_R 0.04409f
C42 PAD_P HS_N_13 0.11642f
C43 PULLDOWN_P HS_N_7 0.06787f
C44 TERM_VCM HS_N_11 0.24046f
C45 TERM_OR_P_B HS_N_1 0.05861f
C46 FS_N_BLEED_3 TERM_TRIM0 0.02029f
C47 FS_P_GATE HS_N_12 0.23512f
C48 FS_PB_GATE FS_PB_BLEED_1 0.29419f
C49 HS_P_7 VDD 5.54336f
C50 FS_P_WELL HS_N_7 0.9854f
C51 TERM_OR_P_S HS_N_12 0.02404f
C52 HS_N DIFF_ENABLE 0.24066f
C53 PULLDOWN_N_R PULLUP_P_CONTROL_S 0.00267f
C54 LS_SLOW FS_P_BLEED_4 1.56752f
C55 HS_N_6 TRIM_P_0_R 0.04808f
C56 TERM_OR_P_S HS_P_9 0.03494f
C57 VCM_LOW_OK TERM_OR_P_NS 1.22445f
C58 PULLUP_N_BLEED_0 VDD 1.13418f
C59 FS_PB_BLEED_0 FS_PB_BLEED_1 0.034f
C60 HS_P_2 HS_N_0 0.02689f
C61 HS_P_7 TRIM_N_1_R 0.04828f
C62 HS_P_0 DIV_LOW_P 0.00786f
C63 FS_N_WELL VDD 0.10557p
C64 PULLDOWN_P FS_N_BLEED_1 0.09468f
C65 FS_N_WELL FS_NB_BLEED_0 0.96553f
C66 FS_PB_BLEED_1 PULLUP_N_OUT 0
C67 PULLUP_N_OUT TERM_OR_N_NS 0.00127f
C68 FS_P_BLEED_0 LS_SLOW 0.85504f
C69 PULLUP_P_OUT FS_P_BLEED_4 0.06987f
C70 HS_N_0 PULLDOWN_N_R 0.06832f
C71 PULLUP_N_OUT TERM_OR_N_B 2.05126f
C72 DIV_N TERM_TRIM2 0.01445f
C73 FS_PB_GATE HS_N_2 0.29305f
C74 TRIM_N_0_R HS_N 0.04828f
C75 PULLDOWN_P PULLUP_N_WELL 1.6058f
C76 LS_SLOW PULLUP_N_CONTROL_S 0.25554f
C77 VDD DIV_LOW_N 0.00118f
C78 LS_SLOW FS_N_OUT 0.52813f
C79 VCM_LOW_OK TERM_OR_P_B 5.27145f
C80 HS_N_0 PAD_N 1.45696f
C81 TERM_TRIM0 VDD 4.1808f
C82 FS_P_WELL FS_PB_BLEED_5 0.02248f
C83 PULLUP_P DIFF_ENABLE 0.06564f
C84 HS_P TERM_OR_P_B 0.07153f
C85 HS_PBIAS HS_N_7 7.23779f
C86 PULLUP_P_OUT FS_P_BLEED_2 0.05628f
C87 LS_SLOW PULLDOWN_P_R 0.23305f
C88 TERM_P_R FS_P_CONTROL_S 0.07373f
C89 PAD_P FS_P_OUT 5.97652f
C90 PULLDOWN_P_R HS_P_5 0.0676f
C91 TERM_VCM PULLUP_P_BLEED_5 0.00196f
C92 FS_P_BLEED_6 HS_N_7 0.04934f
C93 FS_NB_GATE TERM_TRIM2 0.28392f
C94 TERM_TRIM2 HS_N_1 0.03607f
C95 FS_PB_BLEED_0 HS_N_2 0.03931f
C96 TRIM_N_1_R DIV_LOW_N 0.00491f
C97 LS_SLOW PULLUP_N 1.01278f
C98 TRIM_N_1_R TERM_TRIM0 0.02569f
C99 FS_N_WELL FS_NB_BLEED_1 0.00131f
C100 LS_SLOW_B HS_P_5 0
C101 LS_SLOW LS_SLOW_B 4.34455f
C102 PULLUP_N_OUT PULLUP_P_BLEED_0 0.04747f
C103 PULLUP_P_OUT FS_N_OUT 0.06167f
C104 HS_N HS_N_10 3.85199f
C105 PULLUP_P_OUT PULLDOWN_P_R 0.12461f
C106 DIV_LOW_P TRIM_P_2_R 0.0127f
C107 FS_N_GATE HS_N 0.48705f
C108 HS_N_2 HS_P_3 0.02451f
C109 FS_N_BLEED_1 HS_PBIAS 0.01803f
C110 HS_P_11 HS_N_7 0
C111 PULLUP_N_BLEED_6 TERM_TRIM1 0.01462f
C112 TERM_LSA_GATE_P VDD 4.57391f
C113 TRIM_N_0_R PULLUP_P 0.05397f
C114 HS_P_7 HS_P_6 44.9938f
C115 FS_PB_BLEED_5 HS_PBIAS 0.05271f
C116 TERM_LSA_GATE_N LS_SLOW_B 0.09159f
C117 a_43813_117064# a_42245_90628# 0.00994f
C118 HS_N HS_N_11 5.51295f
C119 PULLUP_P_OUT LS_SLOW_B 0.11703f
C120 PULLUP_P_BLEED_5 TRIM_N_2_R 0
C121 FS_P_GATE FS_P_CONTROL_S 0.57683f
C122 DIV_N DIV_P 61.8345f
C123 PULLUP_N_WELL HS_PBIAS 0.4638f
C124 HS_P_4 TERM_P_R 0.11889f
C125 TRIM_N_1_R TERM_LSA_GATE_P 0.06261f
C126 FS_N_WELL FS_LOW_N 0.95364f
C127 PULLUP_N_BLEED_2 PULLUP_N_GATE 0.00339f
C128 VCM_LOW_OK TERM_TRIM2 0.08663f
C129 HS_P TERM_TRIM2 0.00517f
C130 FS_N_WELL FS_NB_CONTROL_LS 0.05546f
C131 TERM_GATE_N PULLUP_N_OUT 0.1771f
C132 RX_N DIV_P 0.37599f
C133 DIV_P HS_N_1 0.04369f
C134 TERM_OR_N_B HS_N_13 0.04867f
C135 TERM_VCM FS_N_BLEED_5 0.0562f
C136 FS_N_GATE PULLUP_P 0.49013f
C137 FS_P_BLEED_4 HS_N_7 0.03931f
C138 FS_LOW_N TERM_TRIM0 0.16617f
C139 TERM_GATE_P_BLEED_0 HS_N_10 0.04001f
C140 HS_P_0 TRIM_N_0_R 0.02846f
C141 HS_P_6 TERM_TRIM0 0.04808f
C142 PULLDOWN_N_R PULLUP_N_BLEED_4 0.09682f
C143 TERM_N_R PULLUP_P_GATE 0.20185f
C144 LS_SLOW PULLUP_P_WELL 3.38531f
C145 FS_N_BLEED_3 FS_N_BLEED_4 0.04499f
C146 TERM_GATE_P_BLEED_0 HS_N_11 0.03985f
C147 HS_N_3 TERM_TRIM0 0.04808f
C148 HS_N_5 TERM_P_R 0.09381f
C149 HS_P_12 HS_P_10 0.08623f
C150 FS_P_BLEED_0 HS_N_7 0
C151 VDD TERM_OR_P_NS 0.00374f
C152 HS_N_2 HS_N_13 0.15703p
C153 TERM_OR_P_S HS_P_4 0.02404f
C154 HS_N_13 PULLUP_P_BLEED_0 0.03931f
C155 TERM_P_R PULLUP_N_GATE 0.17963f
C156 HS_P_7 HS_P_9 0.04283f
C157 PULLUP_P_BLEED_6 TRIM_N_0_R 0.05143f
C158 HS_P_0 HS_N_10 0.06989f
C159 HS_N_8 TERM_P_R 0.13543f
C160 HS_P DIV_P 0.13007f
C161 VCM_LOW_OK DIV_P 0.09439f
C162 PULLUP_P_OUT PULLUP_P_WELL 21.4882f
C163 PULLDOWN_P_R HS_N_7 0.05893f
C164 FS_PB_GATE FS_HIGH_P 0.6347f
C165 HS_P_6 TERM_LSA_GATE_P 0.05893f
C166 HS_N_9 HS_P_12 0.03099f
C167 TERM_ENABLE LS_SLOW 0.08555f
C168 TERM_ENABLE HS_P_5 0.0636f
C169 FS_NB_BLEED_4 PULLUP_N_WELL 0
C170 VDD TERM_OR_P_B 9.17353f
C171 FS_NB_BLEED_6 TERM_TRIM1 0.04303f
C172 FS_N_WELL HS_N_12 0.02092f
C173 HS_P_0 HS_N_11 0.04389f
C174 LS_SLOW_B HS_N_7 0.04331f
C175 HS_N_3 TERM_LSA_GATE_P 0.05893f
C176 TRIM_P_2_R TRIM_N_0_R 0.07364f
C177 FS_PB_CONTROL_LS TERM_N_R 0.05206f
C178 FS_N_BLEED_3 TERM_TRIM2 0.00333f
C179 FS_P_GATE HS_N_5 0.2365f
C180 VDD FS_N_BLEED_4 0.79321f
C181 FS_LOW_P DIV_ENABLE 0.12706f
C182 PULLUP_N_OUT FS_HIGH_P 0.06086f
C183 TRIM_N_1_R TERM_OR_P_B 0.06125f
C184 TERM_GATE_N HS_N_13 0.14691f
C185 HS_N_12 TERM_TRIM0 0.04827f
C186 TERM_OR_P_S HS_N_5 0.02404f
C187 TERM_GATE_N_BLEED_1 HS_PBIAS 0.09581f
C188 TERM_ENABLE TERM_LSA_GATE_N 0.14439f
C189 PULLUP_P_OUT TERM_ENABLE 15.2221f
C190 PULLDOWN_P PULLDOWN_N_R 0.10547p
C191 a_41005_131545# a_41005_132385# 0
C192 LS_SLOW HS_P_8 0.02404f
C193 TERM_VCM HS_N_4 0.24806f
C194 FS_PB_BLEED_5 FS_N_OUT 0.06398f
C195 HS_P_8 HS_P_5 0.03142f
C196 HS_P_9 TERM_TRIM0 0.03494f
C197 HS_P_2 HS_P_13 50.3726f
C198 FS_P_GATE HS_N_8 0.23999f
C199 FS_PB_BLEED_5 PULLDOWN_P_R 0.05251f
C200 PULLUP_N_WELL PULLUP_N_CONTROL_S 0.11536f
C201 PULLUP_P_BLEED_1 PULLUP_P_BLEED_0 0.88599f
C202 FS_P_WELL PULLDOWN_N_R 2.33331f
C203 TERM_OR_P_S HS_N_8 0.02404f
C204 PULLDOWN_N_R HS_P_13 0.07466f
C205 FS_LOW_P TRIM_P_0_R 0.02404f
C206 TERM_N_R TERM_TRIM1 0.24927f
C207 HS_N_2 FS_P_OUT 0.71795f
C208 FS_PB_BLEED_5 LS_SLOW_B 0.06307f
C209 HS_N FS_N_BLEED_5 0.0661f
C210 PAD_N HS_P_13 0.19784f
C211 PULLUP_P_OUT HS_P_8 0.00135f
C212 TERM_TRIM1 FS_PB_BLEED_3 0.01523f
C213 PULLUP_N PULLUP_N_WELL 2.22521f
C214 TERM_LSA_GATE_P HS_N_12 0.05893f
C215 TRIM_N_0_R TERM_GATE_P 0.03672f
C216 TERM_TRIM2 VDD 4.47226f
C217 HS_P_9 TERM_LSA_GATE_P 0.08074f
C218 TERM_GATE_N TERM_GATE_N_BLEED_2 0.93467f
C219 TRIM_P_0_R DIV_ENABLE 0.0625f
C220 HS_P_2 HS_PBIAS 1.9989f
C221 PULLUP_P_WELL HS_N_7 0.12981f
C222 FS_HIGH_P FS_HIGH_N 41.3726f
C223 LS_SLOW HS_N_6 0.07911f
C224 TRIM_N_1_R TERM_TRIM2 0.081f
C225 HS_N_6 HS_P_5 0.10882f
C226 HS_P_6 TERM_OR_P_B 0.08292f
C227 PULLDOWN_N_R HS_PBIAS 0.78481f
C228 PULLUP_P_BLEED_2 HS_N_13 0.03931f
C229 PAD_P TERM_P_R 0.58659f
C230 HS_N_9 PULLUP_P_GATE 0.05635f
C231 PULLUP_P FS_N_BLEED_5 0.06538f
C232 TERM_GATE_P HS_N_10 0.10722f
C233 PULLUP_P_BLEED_6 PULLUP_P_BLEED_5 0.04499f
C234 HS_N_3 TERM_OR_P_B 0.05828f
C235 HS_P_1 HS_N_10 0.03489f
C236 FS_HIGH_P HS_N_13 0.08792f
C237 PULLUP_P_OUT HS_N_6 0.03489f
C238 HS_P_2 HS_P_11 0.02899f
C239 TERM_GATE_P HS_N_11 0.10668f
C240 TERM_ENABLE HS_N_7 0.07958f
C241 PULLUP_P_GATE PULLUP_P_BLEED_4 0.15612f
C242 HS_P_1 HS_N_11 0.03489f
C243 FS_PB_BLEED_5 PULLUP_P_WELL 0.03869f
C244 FS_P_CONTROL_S TERM_TRIM0 0.06894f
C245 DIV_P VDD 0.03347f
C246 TERM_N_R TRIM_P_1_R 0.10053f
C247 PULLDOWN_N_R HS_P_11 0.06792f
C248 PULLUP_N_OUT PULLUP_P_CONTROL_S 0.03724f
C249 FS_PB_GATE HS_N_0 0.29503f
C250 HS_P_7 HS_P_4 0.06174f
C251 HS_P_9 TERM_OR_P_NS 0
C252 HS_N_4 HS_N 1.43714f
C253 HS_P_11 PAD_N 1.45319f
C254 FS_N_CONTROL_S FS_HIGH_N 0.52828f
C255 TERM_TRIM2 FS_LOW_N 0.01625f
C256 PULLUP_P_BLEED_1 PULLUP_P_BLEED_2 0.06543f
C257 HS_P_8 HS_N_7 0.03489f
C258 FS_PB_BLEED_0 HS_N_0 0.04051f
C259 HS_P_6 TERM_TRIM2 0.07775f
C260 HS_N_0 PULLUP_N_OUT 0.04908f
C261 HS_N_12 TERM_OR_P_B 0.05846f
C262 FS_HIGH_P FS_P_BLEED_5 0.21727f
C263 TERM_ENABLE FS_PB_BLEED_5 0.06892f
C264 HS_P_9 TERM_OR_P_B 0.11504f
C265 HS_P_10 TERM_TRIM1 0.03415f
C266 PULLUP_P_BLEED_1 FS_HIGH_P 0.03577f
C267 PULLDOWN_N_R FS_P_BLEED_4 0.05904f
C268 TERM_ENABLE PULLUP_N_WELL 0.56034f
C269 HS_N_0 HS_P_3 0.02686f
C270 HS_P_4 TERM_TRIM0 0.02404f
C271 FS_HIGH_P PULLUP_N_BLEED_1 0.094f
C272 FS_HIGH_P FS_P_OUT 0.79981f
C273 FS_P_BLEED_1 FS_P_WELL 0.14966f
C274 HS_N_9 TERM_TRIM1 0.02572f
C275 FS_NB_GATE FS_NB_CONTROL_S 2.03528f
C276 TERM_VCM TRIM_N_2_R 1.51237f
C277 TERM_GATE_P_BLEED_0 HS_N_4 0.04421f
C278 FS_P_BLEED_0 PULLDOWN_N_R 0.05779f
C279 TERM_P_R PULLDOWN_N 0.78117f
C280 HS_PBIAS FS_N_BLEED_0 0.09588f
C281 HS_P_2 PULLDOWN_P_R 0.02404f
C282 HS_P_7 HS_N_8 0.09161f
C283 HS_N_6 HS_N_7 0.15175p
C284 PULLDOWN_N_R PULLUP_N_CONTROL_S 0.03769f
C285 PULLDOWN_N_R FS_N_OUT 0.82032f
C286 PULLDOWN_N_R PULLDOWN_P_R 41.9769f
C287 HS_P_6 DIV_P 0.07606f
C288 TERM_GATE_P_BLEED_1 HS_P_13 0.03321f
C289 FS_N_WELL FS_N_BLEED_2 0.05213f
C290 PAD_N FS_N_OUT 4.10217f
C291 HS_P_4 TERM_LSA_GATE_P 0.05893f
C292 PULLDOWN_P_R PAD_N 0.22636f
C293 FS_NB_GATE FS_NB_BLEED_6 6.57835f
C294 HS_N_5 TERM_TRIM0 0.04808f
C295 HS_P_0 HS_N_4 0.03432f
C296 DIV_P HS_N_3 0.07757f
C297 PULLDOWN_N_R PULLUP_N 0.09051f
C298 TERM_OR_N_S TERM_OR_N_B 1.40545f
C299 PULLDOWN_N_R LS_SLOW_B 0.0037f
C300 PULLUP_N_GATE TERM_TRIM0 0.15535f
C301 TERM_OR_N_B TERM_P_R 0.10965f
C302 HS_P FS_NB_CONTROL_S 0.03228f
C303 HS_N_8 TERM_TRIM0 0.07654f
C304 HS_P_10 TRIM_P_1_R 0.08509f
C305 HS_N_0 HS_N_13 0.07747f
C306 FS_PB_BLEED_5 HS_N_6 0.03931f
C307 DIV_N TERM_N_R 0
C308 TERM_VCM HS_N 0.41732f
C309 HS_N_5 TERM_LSA_GATE_P 0.05893f
C310 TERM_N_R FS_NB_GATE 0.48168f
C311 HS_N_9 TRIM_P_1_R 0.00363f
C312 TERM_N_R HS_N_1 0.11104f
C313 TERM_P_R HS_N_2 0.09429f
C314 HS_P FS_NB_BLEED_6 0.04828f
C315 ESD_RAIL m2_42279_124800# 5.47988f
C316 TERM_P_R PULLUP_P_BLEED_0 0.04766f
C317 DIV_P HS_N_12 0.04369f
C318 HS_N_8 TERM_LSA_GATE_P 0.05893f
C319 HS_P_9 DIV_P 0.05309f
C320 HS_N_9 TERM_OR_N_PLS 0
C321 HS_P_11 TERM_GATE_P_BLEED_1 0.04516f
C322 TERM_VCM PULLUP_P 0.32405f
C323 HS_N_0 FS_P_BLEED_5 0
C324 PULLDOWN_N_R PULLUP_P_WELL 0.38203f
C325 PULLUP_P_BLEED_1 HS_N_0 0
C326 FS_LOW_P LS_SLOW 0.07013f
C327 HS_P_7 PAD_P 1.58583f
C328 FS_LOW_P HS_P_5 0.08441f
C329 FS_P_BLEED_1 FS_P_BLEED_4 0.1071f
C330 HS_P_4 TERM_OR_P_B 0.08336f
C331 LS_SLOW TERM_OR_P_PLS 0.38245f
C332 FS_PB_GATE FS_P_WELL 0.16117p
C333 HS_N_0 FS_P_OUT 0.86432f
C334 VCM_LOW_OK TERM_N_R 0.05292f
C335 TERM_GATE_N TERM_P_R 0.10212f
C336 HS_P TERM_N_R 0.17296f
C337 FS_P_GATE HS_N_2 0.23429f
C338 FS_P_BLEED_1 FS_P_BLEED_2 0.03688f
C339 HS_P_2 TERM_ENABLE 0.02434f
C340 TERM_TRIM2 FS_P_CONTROL_S 0.03978f
C341 LS_SLOW DIV_ENABLE 0.12664f
C342 TERM_OR_P_S HS_N_2 0.02404f
C343 DIV_ENABLE HS_P_5 0.03996f
C344 HS_P_12 HS_N_10 0.0422f
C345 PULLUP_N_OUT PULLDOWN_P 0.06672f
C346 FS_P_BLEED_0 FS_P_BLEED_1 0.4936f
C347 PULLUP_P_OUT FS_LOW_P 0.15812f
C348 TERM_ENABLE PULLDOWN_N_R 0.13638f
C349 FS_PB_BLEED_0 FS_P_WELL 0.20845f
C350 HS_N_4 TERM_GATE_P 0.105f
C351 PULLUP_P TRIM_N_2_R 0.04377f
C352 HS_P_0 TERM_VCM 0.42617f
C353 PULLUP_P_OUT TERM_OR_P_PLS 0.04138f
C354 HS_P_1 HS_N_4 0.09349f
C355 PULLUP_N_OUT FS_P_WELL 2.29962f
C356 PULLUP_N_OUT HS_P_13 0.08482f
C357 HS_P_12 HS_N_11 0.03425f
C358 TERM_P_R FS_PB_BLEED_4 0.01857f
C359 FS_HIGH_P PULLUP_N_BLEED_2 0.01347f
C360 FS_P_BLEED_1 PULLDOWN_P_R 0.00384f
C361 HS_P_2 HS_P_8 0.00333f
C362 HS_N_5 TERM_OR_P_B 0.05828f
C363 HS_N_6 TERM_GATE_N_BLEED_1 0.04809f
C364 PULLUP_P_OUT DIV_ENABLE 0.06483f
C365 LS_SLOW TRIM_P_0_R 0.08244f
C366 TRIM_P_0_R HS_P_5 0.04808f
C367 FS_PB_GATE HS_PBIAS 0.54056f
C368 HS_P_3 HS_P_13 0.30215f
C369 PULLDOWN_N_R HS_P_8 0.02424f
C370 FS_PB_GATE FS_P_BLEED_6 0.00257f
C371 PULLDOWN_P_R TERM_GATE_P_BLEED_1 0.11369f
C372 TERM_VCM PULLUP_P_BLEED_6 0.05612f
C373 HS_N_8 TERM_OR_P_B 0.05862f
C374 m2_42279_124800# a_41005_133505# 0
C375 DIV_LOW_P TERM_TRIM1 0.05211f
C376 HS_P_8 PAD_N 0.88712f
C377 FS_PB_BLEED_0 HS_PBIAS 0.09588f
C378 HS_P_10 HS_N_1 0.0348f
C379 HS_P_0 TRIM_N_2_R 0.0362f
C380 PULLDOWN_P FS_HIGH_N 0.10929f
C381 HS_N_9 DIV_N 0.04218f
C382 PULLUP_P_OUT TRIM_P_0_R 0.10984f
C383 PULLUP_N_OUT HS_PBIAS 0.7273f
C384 PULLUP_P_GATE TRIM_N_0_R 0.10634f
C385 TERM_VCM TRIM_P_2_R 1.23274f
C386 FS_N_BLEED_3 TERM_N_R 0.06024f
C387 FS_HIGH_P TERM_P_R 0.06133f
C388 FS_NB_BLEED_6 VDD 0.54599f
C389 HS_PBIAS HS_P_3 0.69376f
C390 HS_P_2 HS_N_6 0.05493f
C391 FS_NB_BLEED_6 FS_NB_BLEED_0 0.00257f
C392 HS_N_9 HS_N_1 0.04294f
C393 TERM_GATE_P_BLEED_0 HS_N 0.0523f
C394 PULLUP_N_BLEED_4 PULLUP_N_BLEED_1 0.00929f
C395 PULLDOWN_P HS_N_13 0.06787f
C396 PULLUP_P_BLEED_6 TRIM_N_2_R 0.17234f
C397 HS_N_5 TERM_TRIM2 0.00118f
C398 PULLDOWN_N_R HS_N_6 0.06832f
C399 FS_LOW_P HS_N_7 0.08963f
C400 PULLUP_P_GATE HS_N_10 0.04869f
C401 PULLUP_N_OUT HS_P_11 0.03175f
C402 FS_P_WELL HS_N_13 0.99368f
C403 HS_N_6 PAD_N 1.16702f
C404 HS_P_4 DIV_P 0.04218f
C405 TERM_TRIM2 PULLUP_N_GATE 0.08468f
C406 HS_P HS_P_10 2.4483f
C407 VCM_LOW_OK HS_P_10 0.08296f
C408 HS_N_8 TERM_TRIM2 0.03112f
C409 TRIM_P_2_R TRIM_N_2_R 0.34274f
C410 FS_PB_GATE FS_P_BLEED_4 0.04034f
C411 HS_P_11 HS_P_3 0.07594f
C412 FS_NB_BLEED_6 FS_NB_BLEED_1 0.00257f
C413 DIV_ENABLE HS_N_7 0.08392f
C414 HS_P_0 HS_N 0.54906f
C415 PULLUP_P_GATE HS_N_11 0.04856f
C416 FS_PB_CONTROL_LS TRIM_N_0_R 0.02708f
C417 HS_PBIAS FS_HIGH_N 0.17086f
C418 TERM_TRIM0 PULLDOWN_N 0.03489f
C419 TERM_VCM TERM_GATE_P 16.7378f
C420 FS_HIGH_P FS_P_GATE 4.18668f
C421 TERM_N_R VDD 5.96316f
C422 HS_N_9 VCM_LOW_OK 0.08296f
C423 DIV_LOW_P TRIM_P_1_R 0.00777f
C424 FS_NB_CONTROL_LS FS_NB_CONTROL_S 1.51776f
C425 HS_N_9 HS_P 0.15231p
C426 HS_P_1 TERM_VCM 0.27244f
C427 PULLDOWN_P TERM_GATE_N_BLEED_2 0.09468f
C428 FS_PB_GATE FS_P_BLEED_0 0.06901f
C429 FS_LOW_P FS_PB_BLEED_5 0.07136f
C430 PULLUP_N_OUT FS_P_BLEED_4 0.31023f
C431 TRIM_N_1_R TERM_N_R 0.16688f
C432 FS_N_CONTROL_S TERM_P_R 0.0414f
C433 PULLUP_P_BLEED_1 PULLDOWN_P 0
C434 FS_P_BLEED_1 TERM_ENABLE 0.00533f
C435 HS_N_13 HS_PBIAS 4.92995f
C436 TRIM_P_0_R HS_N_7 0.04808f
C437 FS_LOW_P PULLUP_N_WELL 0.22841f
C438 FS_PB_GATE FS_N_OUT 0.26939f
C439 HS_N_5 DIV_P 0.04369f
C440 TRIM_N_1_R FS_PB_BLEED_3 0
C441 VCM_LOW_OK PULLUP_P_BLEED_4 0.02483f
C442 FS_PB_GATE PULLDOWN_P_R 0.60059f
C443 PULLDOWN_P PULLUP_N_BLEED_1 0.04618f
C444 FS_NB_BLEED_6 FS_LOW_N 0.07127f
C445 TRIM_N_0_R TERM_TRIM1 0.03968f
C446 FS_P_BLEED_6 HS_N_13 0.03753f
C447 FS_P_BLEED_0 PULLUP_N_OUT 0.12465f
C448 FS_PB_BLEED_5 DIV_ENABLE 0.01375f
C449 TERM_GATE_P TRIM_N_2_R 0.03062f
C450 TERM_OR_N_B TERM_TRIM0 0.09407f
C451 HS_N_8 DIV_P 0.04369f
C452 FS_PB_GATE LS_SLOW_B 0.43799f
C453 TERM_GATE_P_BLEED_0 HS_P_0 0.07951f
C454 FS_P_WELL FS_P_OUT 0.12146p
C455 PULLUP_N_WELL DIV_ENABLE 0.02594f
C456 PULLUP_N_OUT PULLUP_N_CONTROL_S 0.0165f
C457 PULLUP_N_OUT FS_N_OUT 0.45324f
C458 FS_LOW_N FS_N_BLEED_6 0.08236f
C459 PULLUP_P_GATE PULLUP_P_BLEED_5 0.25341f
C460 PULLUP_N_OUT PULLDOWN_P_R 0.05324f
C461 RX_P DIV_P 1.39534f
C462 TRIM_N_0_R FS_P_BLEED_3 0.05143f
C463 TERM_TRIM1 HS_N_10 0.02431f
C464 FS_N_GATE TERM_TRIM1 0.50032f
C465 HS_N_2 TERM_TRIM0 0.04808f
C466 TERM_GATE_N_BLEED_2 HS_PBIAS 0.01803f
C467 PULLUP_N_OUT PULLUP_N 0.00105f
C468 PULLDOWN_P_R HS_P_3 0.02404f
C469 PULLUP_N_OUT LS_SLOW_B 0.0482f
C470 TERM_TRIM0 PULLUP_P_BLEED_0 0.03472f
C471 HS_P_8 TERM_GATE_P_BLEED_1 0.03396f
C472 TERM_N_R FS_LOW_N 0.17715f
C473 DIV_N BYPASS_ENABLE 0.09436f
C474 HS_P_6 TERM_N_R 0.04331f
C475 FS_P_BLEED_6 FS_P_BLEED_5 0.06543f
C476 HS_N_0 TERM_P_R 0.13365f
C477 HS_N_11 TERM_TRIM1 0.02427f
C478 HS_PBIAS PULLUP_N_BLEED_1 0.05271f
C479 FS_P_OUT HS_PBIAS 1.28751f
C480 ESD_RAIL a_53878_132665# 0.53916f
C481 RX_N BYPASS_ENABLE 7.32213f
C482 TERM_N_R HS_N_3 0.05893f
C483 FS_P_BLEED_4 HS_N_13 0.03931f
C484 HS_N TERM_GATE_P 0.1846f
C485 FS_HIGH_N FS_N_OUT 0.96033f
C486 HS_P_1 HS_N 0.7913f
C487 HS_N_2 TERM_LSA_GATE_P 0.05893f
C488 TRIM_P_1_R TRIM_N_0_R 0.07364f
C489 DIV_N TERM_GATE_N_BLEED_0 0
C490 HS_P_12 HS_N_4 0.03692f
C491 HS_P_10 VDD 4.55484f
C492 TERM_GATE_N TERM_TRIM0 0.09441f
C493 FS_PB_GATE PULLUP_P_WELL 0.08395f
C494 LS_SLOW_B FS_HIGH_N 0.00377f
C495 HS_N_0 FS_P_GATE 0.23811f
C496 HS_N_6 TERM_GATE_P_BLEED_1 0
C497 TERM_GATE_N_BLEED_0 HS_N_1 0
C498 TRIM_N_1_R HS_P_10 0.02404f
C499 FS_PB_BLEED_0 PULLUP_P_WELL 0
C500 HS_N_9 VDD 4.88405f
C501 HS_N_13 FS_N_OUT 0.12298f
C502 HS_P_0 TRIM_P_2_R 0.00776f
C503 TERM_OR_P_S HS_N_0 0.02404f
C504 PULLDOWN_P_R HS_N_13 0.05893f
C505 PULLUP_N_OUT PULLUP_P_WELL 0.41159f
C506 FS_PB_BLEED_4 TERM_TRIM0 0.02536f
C507 PULLUP_P_BLEED_5 TERM_TRIM1 0.01524f
C508 PAD_P DIV_P 2.63746f
C509 FS_P_BLEED_5 FS_P_BLEED_4 0.88599f
C510 TERM_N_R HS_N_12 0.0597f
C511 FS_PB_GATE TERM_ENABLE 0.59638f
C512 HS_N_9 TRIM_N_1_R 0.04808f
C513 TERM_GATE_P_BLEED_0 TERM_GATE_P 0.28831f
C514 LS_SLOW HS_P_5 0.07544f
C515 LS_SLOW_B HS_N_13 0
C516 TERM_GATE_P_BLEED_0 HS_P_1 0.03311f
C517 FS_NB_BLEED_5 TERM_P_R 0.01857f
C518 HS_P_2 FS_LOW_P 0.08441f
C519 PULLUP_N_OUT TERM_ENABLE 0.19015f
C520 FS_PB_BLEED_6 HS_N_10 0
C521 FS_N_WELL FS_HIGH_P 1.86638f
C522 TERM_P_R PULLUP_N_BLEED_4 0
C523 PULLUP_P_OUT LS_SLOW 0.29121f
C524 PULLUP_P_OUT HS_P_5 0.06724f
C525 TERM_TRIM2 PULLDOWN_N 0.03489f
C526 FS_LOW_P PULLDOWN_N_R 0.11954f
C527 FS_P_BLEED_5 FS_N_OUT 0.35485f
C528 HS_P_0 TERM_GATE_P 0.14972f
C529 PULLUP_P_BLEED_1 FS_N_OUT 0.35543f
C530 PULLDOWN_N_R TERM_OR_P_PLS 0
C531 HS_P_2 DIV_ENABLE 0.03996f
C532 TERM_ENABLE HS_P_3 0.02429f
C533 FS_PB_BLEED_6 HS_N_11 0
C534 HS_P_6 HS_P_10 0.03875f
C535 HS_P_1 HS_P_0 49.6364f
C536 PULLUP_P_BLEED_1 PULLDOWN_P_R 0.00257f
C537 FS_HIGH_P TERM_TRIM0 0.06691f
C538 HS_N_2 TERM_OR_P_B 0.05828f
C539 PULLUP_N_CONTROL_S PULLUP_N_BLEED_1 0
C540 FS_P_OUT FS_N_OUT 1.00178f
C541 PULLDOWN_N_R DIV_ENABLE 0.11082f
C542 PULLUP_P_GATE HS_N_4 0.04808f
C543 PULLUP_N_OUT HS_P_8 0.02846f
C544 PULLDOWN_P_R FS_P_OUT 0.76027f
C545 HS_N_9 FS_LOW_N 0.1275f
C546 TERM_TRIM1 FS_N_BLEED_5 0.04303f
C547 HS_N_9 HS_P_6 0.03089f
C548 PAD_N DIV_ENABLE 0.03382f
C549 PULLUP_N_BLEED_6 PULLUP_N_GATE 0.90627f
C550 HS_P_12 TERM_VCM 0.21279f
C551 HS_P_2 TRIM_P_0_R 0.04808f
C552 PULLUP_N PULLUP_N_BLEED_1 1.57385f
C553 DIV_N TRIM_N_0_R 0.07982f
C554 HS_P_8 HS_P_3 0.00202f
C555 LS_SLOW_B FS_P_OUT 0.28679f
C556 PULLUP_P_WELL HS_N_13 0.12127f
C557 TERM_OR_N_B TERM_TRIM2 0.1005f
C558 HS_N_9 HS_N_3 0.00333f
C559 TERM_ENABLE FS_HIGH_N 0.08124f
C560 FS_PB_GATE HS_N_6 0.29726f
C561 PULLDOWN_N_R TRIM_P_0_R 0.08867f
C562 FS_N_CONTROL_S FS_N_WELL 0.00234f
C563 TRIM_P_2_R TERM_GATE_P 0.03485f
C564 TRIM_N_0_R HS_N_1 0.03489f
C565 PAD_N TRIM_P_0_R 0.53726f
C566 TERM_N_R FS_P_CONTROL_S 0.00559f
C567 PULLDOWN_P TERM_P_R 0.13388f
C568 FS_PB_BLEED_0 HS_N_6 0.04809f
C569 HS_P DIFF_ENABLE 0.1651f
C570 DIV_N HS_N_10 0.04218f
C571 PULLUP_N_OUT HS_N_6 0.0476f
C572 HS_P_10 HS_N_12 0.04371f
C573 FS_N_CONTROL_S TERM_TRIM0 0.02846f
C574 TERM_ENABLE HS_N_13 0.06449f
C575 FS_P_WELL TERM_P_R 1.41462f
C576 TERM_TRIM2 PULLUP_P_BLEED_0 0.03472f
C577 TERM_P_R HS_P_13 0.1574f
C578 HS_P_10 HS_P_9 0.04415f
C579 LS_SLOW HS_N_7 0.08204f
C580 DIV_N HS_N_11 0.04218f
C581 HS_N_6 HS_P_3 0.03089f
C582 HS_N_10 HS_N_1 0.15699p
C583 BYPASS_ENABLE VDD 0.03586f
C584 FS_NB_GATE FS_N_GATE 30.9622f
C585 FS_NB_GATE FS_NB_BLEED_2 0.84237f
C586 PULLUP_P_BLEED_1 PULLUP_P_WELL 0.00602f
C587 HS_N_9 HS_N_12 0.03489f
C588 VCM_LOW_OK TRIM_N_0_R 0.02404f
C589 HS_N_9 HS_P_9 0.09107f
C590 HS_P TRIM_N_0_R 0.03489f
C591 HS_P_8 HS_N_13 0.03489f
C592 HS_N_11 HS_N_1 0.07584f
C593 HS_N_4 TERM_TRIM1 0.02404f
C594 PULLUP_P_OUT HS_N_7 0.03489f
C595 HS_P_1 TERM_GATE_P 0.23409f
C596 TERM_GATE_N TERM_TRIM2 0.07174f
C597 LS_SLOW FS_N_BLEED_1 0.79661f
C598 TERM_P_R HS_PBIAS 0.53801f
C599 PULLUP_N_BLEED_3 PULLUP_N_WELL 0.00181f
C600 FS_P_WELL FS_P_GATE 0.13872p
C601 FS_NB_BLEED_6 PULLUP_N_GATE 0.01058f
C602 LS_SLOW FS_PB_BLEED_5 0.05796f
C603 FS_P_GATE HS_P_13 0.00859f
C604 a_41005_131545# a_41005_131825# 0.03725f
C605 DIV_P HS_N_2 0.04369f
C606 TERM_VCM PULLUP_P_GATE 0.13824f
C607 DIV_LOW_P VDD 0.00233f
C608 TERM_OR_P_S HS_P_13 0.02404f
C609 LS_SLOW PULLUP_N_WELL 0.59959f
C610 HS_P_12 HS_N 0.51547f
C611 HS_P HS_N_10 0.20736f
C612 VCM_LOW_OK HS_N_10 0.08438f
C613 HS_N_0 DIV_LOW_N 0.00889f
C614 HS_N_0 TERM_TRIM0 0.07215f
C615 TERM_ENABLE PULLUP_N_BLEED_1 0.07058f
C616 HS_P FS_N_GATE 0.35186f
C617 TERM_ENABLE FS_P_OUT 0.44875f
C618 HS_P FS_NB_BLEED_2 0.00212f
C619 TERM_TRIM2 FS_PB_BLEED_4 0.06152f
C620 TRIM_N_1_R DIV_LOW_P 0.00817f
C621 PULLUP_P_OUT FS_PB_BLEED_5 0.07005f
C622 TERM_N_R HS_N_5 0.05893f
C623 HS_P HS_N_11 0.76455f
C624 VCM_LOW_OK HS_N_11 0.084f
C625 HS_N_6 HS_N_13 0.08101f
C626 TERM_P_R HS_P_11 0.14201f
C627 FS_P_GATE HS_PBIAS 1.42652f
C628 TERM_N_R PULLUP_N_GATE 0.16643f
C629 TERM_N_R HS_N_8 0.1093f
C630 PULLUP_P_GATE TRIM_N_2_R 0.10951f
C631 HS_P_8 FS_P_OUT 0.05462f
C632 FS_P_GATE FS_P_BLEED_6 0.034f
C633 HS_N_0 TERM_LSA_GATE_P 0.05893f
C634 FS_PB_CONTROL_LS TERM_VCM 0.04991f
C635 HS_N_4 TRIM_P_1_R 0
C636 TERM_GATE_P_BLEED_0 HS_P_12 0.00639f
C637 FS_NB_BLEED_4 TERM_P_R 0.04893f
C638 TERM_P_R FS_P_BLEED_4 0.05771f
C639 FS_LOW_N TERM_GATE_N_BLEED_0 0.0839f
C640 FS_HIGH_P TERM_TRIM2 0.02441f
C641 FS_PB_BLEED_2 FS_PB_BLEED_3 0.03688f
C642 HS_N_6 TERM_GATE_N_BLEED_2 0
C643 FS_P_GATE HS_P_11 0.01352f
C644 TERM_P_R FS_P_BLEED_2 0.04893f
C645 TERM_OR_P_S HS_P_11 0.02404f
C646 TERM_VCM TERM_TRIM1 12.6322f
C647 HS_P_4 HS_P_10 0
C648 FS_NB_BLEED_5 TERM_TRIM0 0.02536f
C649 HS_P_12 HS_P_0 0.08528f
C650 FS_PB_CONTROL_LS TRIM_N_2_R 0.00564f
C651 HS_N_6 FS_P_OUT 0.7159f
C652 PULLUP_P_GATE HS_N 0.09965f
C653 TERM_P_R FS_N_OUT 0.40685f
C654 PULLUP_N_BLEED_6 PULLDOWN_N 0.00832f
C655 TRIM_N_0_R VDD 2.51096f
C656 PULLUP_N_BLEED_5 PULLUP_P 0.83365f
C657 FS_NB_GATE FS_N_BLEED_5 0.04043f
C658 PULLDOWN_P_R TERM_P_R 0.16891f
C659 FS_PB_BLEED_5 HS_N_7 0.03931f
C660 TERM_OR_N_S LS_SLOW_B 0.04806f
C661 FS_P_GATE FS_P_BLEED_4 0.04142f
C662 HS_N_9 HS_P_4 0.03089f
C663 TERM_VCM FS_P_BLEED_3 0.05612f
C664 TRIM_N_1_R TRIM_N_0_R 0.13284p
C665 PULLUP_N TERM_P_R 0.17522f
C666 TERM_P_R LS_SLOW_B 0.42133f
C667 FS_PB_GATE FS_LOW_P 0.45092f
C668 TERM_TRIM1 TRIM_N_2_R 0.03f
C669 FS_N_CONTROL_S TERM_TRIM2 0.06757f
C670 FS_P_BLEED_0 FS_P_GATE 0.08333f
C671 HS_P_10 HS_N_5 0.03089f
C672 HS_N_0 TERM_OR_P_B 0.05832f
C673 HS_N_12 TERM_GATE_N_BLEED_0 0
C674 VDD HS_N_10 5.14062f
C675 FS_N_GATE VDD 25.0099f
C676 FS_LOW_N DIFF_ENABLE 0.28578f
C677 PULLUP_P_GATE PULLUP_P 0.55998f
C678 PAD_P TERM_N_R 0.19272f
C679 FS_P_GATE FS_N_OUT 0.21414f
C680 HS_P_2 HS_P_5 0.00106f
C681 HS_P_2 LS_SLOW 0.02436f
C682 FS_NB_BLEED_3 PULLDOWN_P 0.00384f
C683 HS_P_7 HS_P_13 0.09795f
C684 FS_PB_GATE DIV_ENABLE 0.00243f
C685 FS_P_GATE PULLDOWN_P_R 0.51934f
C686 HS_P_10 HS_N_8 0.02872f
C687 TERM_OR_P_S FS_N_OUT 0.05082f
C688 FS_N_WELL PULLDOWN_P 1.83754f
C689 TRIM_N_1_R HS_N_10 0.04987f
C690 HS_N_11 VDD 6.02825f
C691 HS_P FS_N_BLEED_5 0.05271f
C692 PULLUP_N_OUT FS_LOW_P 0.05379f
C693 TERM_OR_P_S PULLDOWN_P_R 0.03671f
C694 HS_N_9 HS_N_5 0.04079f
C695 FS_P_BLEED_3 TRIM_N_2_R 0.17234f
C696 LS_SLOW PULLDOWN_N_R 0.17499f
C697 TERM_VCM TRIM_P_1_R 0.84484f
C698 PULLDOWN_N_R HS_P_5 0.07217f
C699 ESD_RAIL a_41005_133505# 0.53842f
C700 PULLUP_N_OUT TERM_OR_P_PLS 0.32544f
C701 DIV_N HS_N_4 0.04218f
C702 FS_P_GATE LS_SLOW_B 0.29345f
C703 LS_SLOW PAD_N 0.01004f
C704 PULLDOWN_P DIV_LOW_N 0.0037f
C705 FS_LOW_P HS_P_3 0.08441f
C706 TRIM_N_1_R HS_N_11 0.04942f
C707 PAD_N HS_P_5 1.58373f
C708 PULLDOWN_P TERM_TRIM0 0.03698f
C709 TERM_OR_P_S LS_SLOW_B 0.09731f
C710 HS_N_9 HS_N_8 0.15034p
C711 PULLUP_N_OUT DIV_ENABLE 0.12115f
C712 FS_NB_BLEED_1 FS_NB_BLEED_2 0.034f
C713 FS_LOW_N TRIM_N_0_R 0.0195f
C714 HS_P_6 TRIM_N_0_R 0.02476f
C715 FS_P_WELL TERM_TRIM0 1.34565f
C716 HS_N_4 HS_N_1 0.04305f
C717 PULLUP_P_OUT PULLDOWN_N_R 0.10363f
C718 HS_P_7 HS_PBIAS 8.26123f
C719 HS_N TERM_TRIM1 0.0551f
C720 TERM_P_R PULLUP_P_WELL 0.34796f
C721 TERM_TRIM0 HS_P_13 0.04808f
C722 DIV_ENABLE HS_P_3 0.03996f
C723 HS_P_12 TERM_GATE_P 0.184f
C724 HS_N_0 TERM_TRIM2 0.09185f
C725 PULLUP_P_OUT PAD_N 0.28155f
C726 HS_N_3 TRIM_N_0_R 0.03489f
C727 HS_P_1 HS_P_12 0.03142f
C728 PULLUP_N_OUT TRIM_P_0_R 0.1108f
C729 TRIM_P_1_R TRIM_N_2_R 0.28022f
C730 a_53878_132105# a_53878_132665# 0.0346f
C731 FS_LOW_P FS_HIGH_N 0.18695f
C732 TERM_OR_N_S TERM_ENABLE 0.25841f
C733 FS_N_WELL HS_PBIAS 2.61113f
C734 TERM_GATE_N_BLEED_1 HS_N_7 0.05151f
C735 FS_LOW_N HS_N_10 0.08505f
C736 FS_LOW_N FS_N_GATE 0.38731f
C737 PULLUP_P_GATE PULLUP_P_BLEED_6 0.97176f
C738 a_41005_131545# a_41005_132945# 0
C739 HS_P_6 HS_N_10 0.03425f
C740 FS_NB_CONTROL_LS FS_N_GATE 0.00174f
C741 TRIM_P_0_R HS_P_3 0.04808f
C742 HS_P_7 HS_P_11 0.04469f
C743 TERM_ENABLE TERM_P_R 0.70776f
C744 HS_PBIAS DIV_LOW_N 0.01675f
C745 TERM_LSA_GATE_P HS_P_13 0.05893f
C746 FS_LOW_N HS_N_11 0.08505f
C747 TRIM_N_1_R PULLUP_P_BLEED_5 0
C748 TERM_TRIM1 PULLUP_P 0.04377f
C749 TERM_TRIM0 HS_PBIAS 0.40567f
C750 FS_PB_CONTROL_LS FS_PB_CONTROL_S 1.54384f
C751 DIV_ENABLE FS_HIGH_N 5.06019f
C752 HS_N_3 HS_N_10 0.07409f
C753 VCM_LOW_OK HS_N_4 0.08296f
C754 FS_N_BLEED_3 FS_N_BLEED_5 0.25341f
C755 HS_P HS_N_4 0.32519f
C756 HS_P_6 HS_N_11 0.03425f
C757 TERM_N_R PULLDOWN_N 0.20696f
C758 FS_LOW_P HS_N_13 0.08963f
C759 HS_N_3 HS_N_11 0.06439f
C760 TRIM_N_0_R HS_N_12 0.03489f
C761 HS_N_0 DIV_P 0.07758f
C762 PAD_P HS_P_10 1.33573f
C763 HS_P_8 TERM_P_R 0.11785f
C764 HS_N_13 DIV_ENABLE 0.08392f
C765 HS_P_2 HS_N_7 0.02404f
C766 HS_P_11 TERM_TRIM0 0.02404f
C767 TERM_ENABLE FS_P_GATE 0.40106f
C768 HS_P_0 TERM_TRIM1 0.03924f
C769 PULLDOWN_N_R HS_N_7 0.06832f
C770 FS_NB_BLEED_3 FS_NB_BLEED_4 0.03688f
C771 TERM_OR_P_S TERM_ENABLE 1.80527f
C772 HS_N_9 PAD_P 1.26206f
C773 DIV_N TERM_VCM 0.85727f
C774 FS_NB_BLEED_5 TERM_TRIM2 0.06152f
C775 TERM_N_R TERM_OR_N_B 0.14883f
C776 FS_N_BLEED_5 FS_NB_BLEED_0 0
C777 HS_N_12 HS_N_10 0.011f
C778 VDD FS_N_BLEED_5 0.54467f
C779 PAD_N ESD_RAIL 44.507f
C780 PAD_N HS_N_7 1.79196f
C781 FS_LOW_P FS_P_BLEED_5 0.1364f
C782 TRIM_P_0_R HS_N_13 0.04867f
C783 FS_N_GATE HS_N_12 0.02237f
C784 HS_P_9 HS_N_10 0.02545f
C785 FS_P_BLEED_1 LS_SLOW 0.04808f
C786 PULLUP_P_BLEED_1 FS_LOW_P 0.1364f
C787 FS_NB_GATE TERM_VCM 0.32199f
C788 FS_PB_BLEED_6 HS_N 0.02585f
C789 TERM_VCM HS_N_1 0.29009f
C790 HS_N_12 HS_N_11 0.16866p
C791 FS_P_GATE HS_P_8 0.00226f
C792 FS_LOW_P PULLUP_N_BLEED_1 0.06271f
C793 FS_NB_BLEED_4 TERM_TRIM0 0.02029f
C794 HS_P_7 PULLDOWN_P_R 0.0676f
C795 FS_LOW_P FS_P_OUT 0.53506f
C796 PULLUP_P_BLEED_6 TERM_TRIM1 0.1244f
C797 TERM_LSA_GATE_P HS_P_11 0.05893f
C798 FS_P_BLEED_4 TERM_TRIM0 0.04477f
C799 HS_P_9 HS_N_11 0.02508f
C800 TERM_OR_P_S HS_P_8 0.02404f
C801 HS_N_6 TERM_P_R 0.09381f
C802 FS_P_BLEED_5 DIV_ENABLE 0
C803 TERM_N_R HS_N_2 0.0594f
C804 PULLDOWN_N_R FS_N_BLEED_1 0.05831f
C805 PULLUP_P_BLEED_1 DIV_ENABLE 0
C806 LS_SLOW TERM_GATE_P_BLEED_1 0.28982f
C807 PULLDOWN_N_R FS_PB_BLEED_5 0.05924f
C808 TERM_N_R PULLUP_P_BLEED_0 0.05399f
C809 TERM_GATE_P_BLEED_1 HS_P_5 0.03151f
C810 DIV_N TRIM_N_2_R 0.0771f
C811 TERM_OR_P_B HS_P_13 0.08486f
C812 FS_P_BLEED_2 TERM_TRIM0 0.02029f
C813 HS_P_7 LS_SLOW_B 0.05016f
C814 PULLUP_P_OUT FS_P_BLEED_1 0.0565f
C815 FS_N_WELL FS_N_OUT 0.12932p
C816 DIV_ENABLE PULLUP_N_BLEED_1 0.03564f
C817 PULLDOWN_N_R PULLUP_N_WELL 0.32365f
C818 FS_P_OUT DIV_ENABLE 0.08741f
C819 TRIM_P_2_R TERM_TRIM1 0.03483f
C820 RX_P BYPASS_ENABLE 4.97887f
C821 HS_N_1 TRIM_N_2_R 0.00776f
C822 HS_N_9 PULLUP_P_BLEED_3 0.00148f
C823 TERM_TRIM0 FS_N_OUT 0.24375f
C824 FS_N_WELL LS_SLOW_B 1.46923f
C825 HS_P TERM_VCM 0.42175f
C826 VCM_LOW_OK TERM_VCM 8.72056f
C827 FS_P_CONTROL_S TRIM_N_0_R 0.04601f
C828 PULLDOWN_P_R TERM_TRIM0 0.03671f
C829 HS_P_0 TRIM_P_1_R 0.02142f
C830 FS_P_GATE HS_N_6 0.23739f
C831 TERM_GATE_N TERM_N_R 16.5672f
C832 FS_P_OUT TRIM_P_0_R 0.10852f
C833 FS_LOW_N FS_N_BLEED_5 0.07018f
C834 TERM_OR_P_S HS_N_6 0.02404f
C835 LS_SLOW_B DIV_LOW_N 0
C836 PULLDOWN_P TERM_TRIM2 0.03698f
C837 LS_SLOW_B TERM_TRIM0 0.08662f
C838 HS_N_4 VDD 5.45918f
C839 PULLUP_P_BLEED_3 PULLUP_P_BLEED_4 0.18357f
C840 FS_P_WELL TERM_TRIM2 1.17122f
C841 TERM_GATE_P TERM_TRIM1 0
C842 DIV_N HS_N 0.05885f
C843 TERM_TRIM2 HS_P_13 0.07707f
C844 TERM_LSA_GATE_P FS_N_OUT 0.1125f
C845 TRIM_N_1_R HS_N_4 0.04809f
C846 VCM_LOW_OK TRIM_N_2_R 0.0362f
C847 PULLDOWN_P_R TERM_LSA_GATE_P 0.08427f
C848 HS_P_1 TERM_TRIM1 0.07952f
C849 HS_P TRIM_N_2_R 0
C850 PULLDOWN_P_R TERM_GATE_P_BLEED_2 0.00488f
C851 FS_HIGH_P FS_NB_BLEED_6 0.09407f
C852 FS_PB_BLEED_4 FS_PB_BLEED_3 0.04499f
C853 HS_P_11 TERM_OR_P_B 0.10086f
C854 FS_NB_GATE HS_N 0.53102f
C855 HS_N HS_N_1 3.90933f
C856 LS_SLOW_B TERM_LSA_GATE_P 0.2136f
C857 TRIM_P_1_R TRIM_P_2_R 25.5277f
C858 HS_N_9 FS_PB_BLEED_1 0.00148f
C859 HS_N_9 TERM_OR_N_NS 0.01002f
C860 FS_HIGH_P FS_N_BLEED_6 0.01347f
C861 HS_N_9 TERM_OR_N_B 0.04851f
C862 FS_N_BLEED_1 FS_N_BLEED_0 0.034f
C863 PAD_P BYPASS_ENABLE 8.2341f
C864 TERM_TRIM2 HS_PBIAS 0.41886f
C865 FS_PB_GATE LS_SLOW 40.9257f
C866 HS_P_10 HS_N_2 0.03089f
C867 HS_P_7 TERM_ENABLE 0.07877f
C868 FS_N_BLEED_3 TERM_VCM 0.00196f
C869 a_53878_132665# a_53878_133225# 0.0346f
C870 TERM_GATE_P_BLEED_1 HS_N_7 0
C871 PULLUP_P_WELL TERM_TRIM0 0.33917f
C872 PULLUP_N_OUT PULLUP_N_BLEED_3 0
C873 DIV_P HS_P_13 0.04221f
C874 FS_HIGH_P TERM_N_R 0.15851f
C875 FS_NB_GATE PULLUP_P 0.7073f
C876 FS_LOW_N HS_N_4 0.08505f
C877 FS_NB_BLEED_3 TERM_ENABLE 0.01311f
C878 PULLUP_P HS_N_1 0.05062f
C879 HS_N_5 TRIM_N_0_R 0.03489f
C880 HS_P HS_N 2.27756f
C881 HS_P_6 HS_N_4 0.03586f
C882 HS_N_9 HS_N_2 0
C883 VCM_LOW_OK HS_N 0.14154f
C884 PULLDOWN_P_R TERM_OR_P_NS 0.02198f
C885 PULLUP_N_OUT LS_SLOW 21.4771f
C886 FS_N_WELL TERM_ENABLE 2.78526f
C887 PULLUP_N_OUT HS_P_5 0.07788f
C888 TERM_GATE_P_BLEED_0 HS_N_1 0.04023f
C889 HS_N_9 PULLUP_P_BLEED_0 0.03931f
C890 PULLUP_P_OUT FS_PB_GATE 0.89181f
C891 ESD_RAIL a_42245_90628# 0.24349p
C892 HS_P_7 HS_P_8 44.3036f
C893 TRIM_P_1_R TERM_GATE_P 0.02827f
C894 HS_N_8 TRIM_N_0_R 0.03489f
C895 HS_N_4 HS_N_3 0.15429p
C896 HS_P_1 TRIM_P_1_R 0.093f
C897 LS_SLOW_B TERM_OR_P_NS 0
C898 LS_SLOW HS_P_3 0.02431f
C899 TERM_ENABLE DIV_LOW_N 0.04605f
C900 HS_P_3 HS_P_5 0.00347f
C901 TERM_ENABLE TERM_TRIM0 0.09825f
C902 FS_LOW_P PULLUP_N_BLEED_2 0.05872f
C903 TERM_OR_P_B FS_N_OUT 0.06103f
C904 HS_P_2 PULLDOWN_N_R 0.02404f
C905 TERM_VCM VDD 15.1117f
C906 HS_N_5 HS_N_10 0
C907 PULLUP_P_BLEED_4 PULLUP_P_BLEED_0 0.00412f
C908 PULLUP_P_OUT PULLUP_N_OUT 0.24573f
C909 PULLDOWN_P_R TERM_OR_P_B 0.12082f
C910 DIV_P HS_PBIAS 0.0013f
C911 HS_P_2 PAD_N 2.46617f
C912 HS_P_0 HS_N_1 0.04113f
C913 VCM_LOW_OK PULLUP_P 0.07405f
C914 HS_N_9 TERM_GATE_N 0.14996f
C915 PULLUP_N_BLEED_2 DIV_ENABLE 0
C916 LS_SLOW_B TERM_OR_P_B 0.15411f
C917 HS_N_5 HS_N_11 0
C918 FS_NB_BLEED_4 TERM_TRIM2 0.00333f
C919 FS_N_GATE FS_N_BLEED_2 0.01215f
C920 TRIM_N_1_R TERM_VCM 1.17479f
C921 TERM_TRIM2 FS_P_BLEED_4 0.04294f
C922 PULLDOWN_N_R PAD_N 4.60168f
C923 ESD_RAIL a_53878_132105# 0.53942f
C924 TERM_GATE_P_BLEED_0 HS_P 0.11246f
C925 HS_P_8 TERM_TRIM0 0.02404f
C926 FS_N_CONTROL_S TERM_N_R 0.05206f
C927 LS_SLOW FS_HIGH_N 0.09451f
C928 TERM_ENABLE TERM_LSA_GATE_P 0.24233f
C929 TERM_TRIM2 FS_P_BLEED_2 0.00333f
C930 TERM_ENABLE TERM_GATE_P_BLEED_2 0.00512f
C931 HS_N_4 HS_N_12 0
C932 DIV_P HS_P_11 0.04275f
C933 VDD TRIM_N_2_R 14.7694f
C934 HS_P_9 HS_N_4 0.02404f
C935 FS_LOW_P TERM_P_R 0.38727f
C936 VCM_LOW_OK FS_PB_CONTROL_S 0.07642f
C937 LS_SLOW HS_N_13 0.0773f
C938 TERM_TRIM2 FS_N_OUT 0.31885f
C939 VCM_LOW_OK HS_P_0 0.1501f
C940 TRIM_N_1_R TRIM_N_2_R 0.13218p
C941 HS_P HS_P_0 22.5374f
C942 PULLDOWN_P_R TERM_TRIM2 0.00701f
C943 FS_PB_GATE HS_N_7 0.29846f
C944 HS_P_8 TERM_LSA_GATE_P 0.05893f
C945 TERM_P_R DIV_ENABLE 0.07184f
C946 HS_N_6 TERM_TRIM0 0.04808f
C947 ESD_RAIL a_53878_134345# 0.5677f
C948 TERM_VCM FS_LOW_N 0.14437f
C949 TERM_TRIM2 LS_SLOW_B 0.08662f
C950 HS_N_9 PULLUP_P_BLEED_2 0.06246f
C951 HS_P_6 TERM_VCM 0.2433f
C952 FS_PB_BLEED_0 HS_N_7 0.05151f
C953 PULLUP_P_OUT HS_N_13 0.03489f
C954 PAD_P TRIM_N_0_R 0.00129f
C955 PULLUP_N_OUT HS_N_7 0.05659f
C956 FS_LOW_P FS_P_GATE 0.33537f
C957 TERM_ENABLE TERM_OR_P_NS 0.03052f
C958 HS_N_0 TERM_N_R 0.10509f
C959 DIV_N TERM_GATE_P 0.01418f
C960 TERM_VCM HS_N_3 0.24637f
C961 HS_N_9 FS_HIGH_P 0.09916f
C962 TERM_OR_P_S FS_LOW_P 4.22628f
C963 TERM_P_R TRIM_P_0_R 0.16104f
C964 HS_N FS_NB_BLEED_0 0.02215f
C965 HS_N VDD 2.5346f
C966 HS_P_1 DIV_N 0.01203f
C967 FS_PB_GATE FS_PB_BLEED_5 0.60324f
C968 LS_SLOW TERM_GATE_N_BLEED_2 0.18014f
C969 TERM_OR_P_S TERM_OR_P_PLS 0
C970 PULLUP_N_BLEED_3 PULLUP_N_BLEED_1 0.00131f
C971 VCM_LOW_OK TRIM_P_2_R 0.02501f
C972 DIV_P FS_N_OUT 2.27208f
C973 FS_P_GATE DIV_ENABLE 0.00182f
C974 HS_N_6 TERM_LSA_GATE_P 0.05893f
C975 TERM_GATE_P HS_N_1 0.1081f
C976 PULLDOWN_P_R DIV_P 0.05485f
C977 FS_LOW_N TRIM_N_2_R 0.00224f
C978 TRIM_N_1_R HS_N 0.1377f
C979 TERM_OR_P_S DIV_ENABLE 0.00795f
C980 BYPASS_ENABLE PULLUP_P_BLEED_0 0.00766f
C981 TERM_ENABLE TERM_OR_P_B 2.78924f
C982 PAD_P HS_N_10 0.15438f
C983 HS_P_6 TRIM_N_2_R 0.00514f
C984 HS_P_1 HS_N_1 0.12555f
C985 HS_P_8 TERM_OR_P_NS 0
C986 LS_SLOW PULLUP_N_BLEED_1 0.06637f
C987 FS_PB_BLEED_0 FS_PB_BLEED_5 0.00257f
C988 PULLUP_N_OUT FS_N_BLEED_1 0
C989 HS_P_12 TERM_TRIM1 0.02413f
C990 LS_SLOW FS_P_OUT 0.451f
C991 FS_NB_BLEED_5 FS_NB_BLEED_6 0.97237f
C992 PULLUP_N_OUT FS_PB_BLEED_5 0.0709f
C993 FS_NB_BLEED_1 HS_N 0.24283f
C994 PAD_P HS_N_11 0.42337f
C995 PULLUP_N_OUT PULLUP_N_WELL 25.8162f
C996 PULLUP_P_OUT PULLUP_P_BLEED_1 0
C997 PULLDOWN_N DIFF_ENABLE 0.1225f
C998 PULLUP_P VDD 2.11056f
C999 FS_P_BLEED_1 PULLDOWN_N_R 0.00195f
C1000 TERM_TRIM2 PULLUP_P_WELL 0.28884f
C1001 TERM_VCM HS_N_12 0.24043f
C1002 TERM_OR_P_S TRIM_P_0_R 0.03768f
C1003 HS_P_8 TERM_OR_P_B 0.08232f
C1004 PULLUP_P_OUT FS_P_OUT 0.58816f
C1005 HS_P_2 TERM_GATE_P_BLEED_1 0.03224f
C1006 HS_P_9 TERM_VCM 0.28099f
C1007 TERM_GATE_N BYPASS_ENABLE 0.00766f
C1008 FS_N_BLEED_5 FS_N_BLEED_2 0.1071f
C1009 TRIM_N_1_R PULLUP_P 0.04377f
C1010 VCM_LOW_OK TERM_GATE_P 16.0215f
C1011 HS_P TERM_GATE_P 0.13609f
C1012 PULLDOWN_N_R TERM_GATE_P_BLEED_1 0.06216f
C1013 HS_P_1 VCM_LOW_OK 0.08296f
C1014 HS_P_1 HS_P 4.20825f
C1015 HS_N_13 HS_N_7 0.09546f
C1016 FS_LOW_N HS_N 0.11427f
C1017 TERM_ENABLE TERM_TRIM2 0.09825f
C1018 HS_P_6 HS_N 0.45424f
C1019 PULLDOWN_P FS_NB_CONTROL_S 0.17487f
C1020 TERM_GATE_N TERM_GATE_N_BLEED_0 0.88646f
C1021 HS_P_4 HS_N_4 0
C1022 HS_P_0 VDD 3.86238f
C1023 PULLUP_N_WELL FS_HIGH_N 0.15629f
C1024 HS_P_9 TRIM_N_2_R 0.00112f
C1025 HS_N_3 HS_N 2.50774f
C1026 HS_P_12 TRIM_P_1_R 0.09608f
C1027 HS_N_6 TERM_OR_P_B 0.05828f
C1028 TRIM_N_1_R HS_P_0 0.05461f
C1029 PULLDOWN_P FS_NB_BLEED_6 0.37855f
C1030 FS_PB_BLEED_5 HS_N_13 0.03931f
C1031 TERM_GATE_N_BLEED_2 HS_N_7 0
C1032 PULLUP_P_BLEED_6 VDD 0.79321f
C1033 FS_LOW_N PULLUP_P 0.05062f
C1034 PULLUP_P_GATE TERM_TRIM1 0.2446f
C1035 FS_NB_CONTROL_LS PULLUP_P 0.65611f
C1036 TERM_OR_N_B TRIM_N_0_R 0.06409f
C1037 HS_N_9 HS_N_0 0.03911f
C1038 HS_N_5 HS_N_4 0.15388p
C1039 TRIM_N_1_R PULLUP_P_BLEED_6 0.04016f
C1040 TERM_ENABLE DIV_P 0.00156f
C1041 FS_HIGH_P BYPASS_ENABLE 0
C1042 FS_NB_CONTROL_S HS_PBIAS 0.09364f
C1043 TRIM_P_2_R VDD 7.23842f
C1044 FS_P_OUT HS_N_7 0.80736f
C1045 ESD_RAIL a_53878_133225# 0.53916f
C1046 HS_P_7 FS_LOW_P 0.08441f
C1047 TERM_VCM FS_P_CONTROL_S 0.03969f
C1048 HS_N_8 HS_N_4 0.04062f
C1049 HS_N HS_N_12 8.8143f
C1050 TERM_GATE_P_BLEED_0 HS_N_3 0.04313f
C1051 HS_P_9 HS_N 0.19415f
C1052 HS_N_2 TRIM_N_0_R 0.03489f
C1053 PULLDOWN_P TERM_N_R 0.24493f
C1054 TRIM_N_1_R TRIM_P_2_R 0.06475f
C1055 TERM_OR_N_B HS_N_10 0.04949f
C1056 TRIM_N_0_R PULLUP_P_BLEED_0 0.03472f
C1057 HS_N_6 TERM_TRIM2 0.00155f
C1058 HS_P_7 DIV_ENABLE 0.03996f
C1059 HS_P_6 HS_P_0 0.07589f
C1060 HS_P_8 DIV_P 0.04218f
C1061 FS_N_WELL FS_LOW_P 1.64171f
C1062 FS_HIGH_P TERM_GATE_N_BLEED_0 0.01347f
C1063 FS_NB_BLEED_6 HS_PBIAS 0.04828f
C1064 FS_PB_GATE PULLDOWN_N_R 0.68725f
C1065 FS_PB_CONTROL_LS TERM_TRIM1 0.04765f
C1066 FS_P_WELL TERM_N_R 1.36666f
C1067 PULLUP_N_BLEED_3 PULLUP_N_BLEED_2 0.06543f
C1068 TERM_N_R HS_P_13 0.04331f
C1069 TERM_OR_N_B HS_N_11 0.04911f
C1070 FS_P_CONTROL_S TRIM_N_2_R 0.14411f
C1071 HS_P_2 PULLUP_N_OUT 0.02882f
C1072 FS_LOW_P TERM_TRIM0 0.06682f
C1073 PULLUP_N_WELL PULLUP_N_BLEED_1 0.8731f
C1074 HS_N_2 HS_N_10 0.04415f
C1075 FS_N_WELL DIV_ENABLE 0.29569f
C1076 HS_N_12 PULLUP_P 0
C1077 TERM_GATE_P VDD 7.47607f
C1078 HS_P_4 TERM_VCM 0.1923f
C1079 HS_N_10 PULLUP_P_BLEED_0 0.03931f
C1080 HS_P_7 TRIM_P_0_R 0.04808f
C1081 TERM_GATE_N TRIM_N_0_R 0.62351f
C1082 HS_P_1 VDD 4.28959f
C1083 PULLUP_N_OUT PULLDOWN_N_R 0.12053f
C1084 TERM_GATE_P_BLEED_0 HS_N_12 0.03973f
C1085 HS_P_2 HS_P_3 48.3284f
C1086 DIV_ENABLE DIV_LOW_N 1.4127f
C1087 PULLUP_N_OUT PAD_N 1.37346f
C1088 HS_N_2 HS_N_11 0.03504f
C1089 TRIM_N_1_R TERM_GATE_P 0.033f
C1090 DIV_ENABLE TERM_TRIM0 0.09155f
C1091 HS_N_11 PULLUP_P_BLEED_0 0.03931f
C1092 PULLDOWN_N_R HS_P_3 0.02404f
C1093 TERM_N_R HS_PBIAS 0.71856f
C1094 HS_P_1 TRIM_N_1_R 0.02404f
C1095 DIV_N HS_P_12 0
C1096 HS_N_6 DIV_P 0.04369f
C1097 TERM_GATE_N_BLEED_1 HS_N_13 0.03931f
C1098 FS_LOW_P TERM_LSA_GATE_P 0.19943f
C1099 PAD_N HS_P_3 0.2857f
C1100 TERM_P_R PULLUP_N_BLEED_3 0.00257f
C1101 TRIM_N_0_R FS_PB_BLEED_4 0.05143f
C1102 FS_PB_BLEED_6 PULLUP_P_GATE 0
C1103 TERM_GATE_N HS_N_10 0.14834f
C1104 HS_P_0 HS_N_12 0.04378f
C1105 TERM_LSA_GATE_P TERM_OR_P_PLS 0.23515f
C1106 HS_P_4 TRIM_N_2_R 0
C1107 HS_P_12 HS_N_1 0.02846f
C1108 HS_N_5 TERM_VCM 0.2505f
C1109 FS_P_BLEED_3 TERM_TRIM1 0.12586f
C1110 TRIM_P_0_R TERM_TRIM0 6.56286f
C1111 LS_SLOW TERM_P_R 0.65633f
C1112 TERM_P_R HS_P_5 0.11863f
C1113 HS_P_0 HS_P_9 0.0418f
C1114 FS_NB_BLEED_4 FS_NB_BLEED_6 0.23498f
C1115 FS_HIGH_P DIFF_ENABLE 0.20577f
C1116 TERM_LSA_GATE_P DIV_ENABLE 0.01435f
C1117 TERM_GATE_N HS_N_11 0.14784f
C1118 PAD_P HS_N_4 0.10327f
C1119 TERM_VCM PULLUP_N_GATE 0.08073f
C1120 PULLDOWN_N_R FS_HIGH_N 0.11584f
C1121 HS_N_8 TERM_VCM 0.30984f
C1122 TERM_GATE_N_BLEED_2 TERM_GATE_N_BLEED_1 0.034f
C1123 TERM_P_R TERM_LSA_GATE_N 2.71987f
C1124 PULLUP_P_OUT TERM_P_R 0.34872f
C1125 HS_P_2 HS_N_13 0.02464f
C1126 LS_SLOW_B FS_NB_CONTROL_S 0.53671f
C1127 HS_P_6 TERM_GATE_P 0.15367f
C1128 TERM_LSA_GATE_P TRIM_P_0_R 0.05534f
C1129 HS_P_6 HS_P_1 0.03867f
C1130 FS_HIGH_P TRIM_N_0_R 0.01049f
C1131 HS_P_12 VCM_LOW_OK 0.12867f
C1132 PULLDOWN_N_R HS_N_13 0.06832f
C1133 HS_P_12 HS_P 3.60508f
C1134 LS_SLOW FS_P_GATE 0.45982f
C1135 TRIM_P_1_R TERM_TRIM1 5.00289f
C1136 FS_LOW_P TERM_OR_P_NS 0.27345f
C1137 HS_P_10 HS_P_13 0.05941f
C1138 FS_NB_BLEED_4 TERM_N_R 0.34348f
C1139 HS_N_3 TERM_GATE_P 0.105f
C1140 TERM_N_R FS_P_BLEED_4 0.06307f
C1141 TERM_OR_P_S LS_SLOW 0.05065f
C1142 HS_N_9 PULLDOWN_P 0.02404f
C1143 PAD_N HS_N_13 1.59165f
C1144 TERM_OR_P_S HS_P_5 0.02404f
C1145 HS_P_4 HS_N 0.15877f
C1146 HS_N_8 TRIM_N_2_R 0
C1147 HS_P_1 HS_N_3 0.03489f
C1148 PULLUP_P_BLEED_2 HS_N_10 0.04001f
C1149 HS_N_0 TERM_GATE_N_BLEED_0 0
C1150 TERM_N_R FS_P_BLEED_2 0.06024f
C1151 HS_N_9 FS_P_WELL 1.05684f
C1152 FS_PB_GATE FS_P_BLEED_1 0.04152f
C1153 HS_N_9 HS_P_13 0.03097f
C1154 PULLUP_P_OUT FS_P_GATE 0.60909f
C1155 DIV_N PULLUP_P_GATE 0.00135f
C1156 FS_LOW_P TERM_OR_P_B 5.92341f
C1157 PULLUP_P_BLEED_2 HS_N_11 0.03985f
C1158 FS_HIGH_P HS_N_10 0.08824f
C1159 TERM_ENABLE PULLUP_N_BLEED_6 0.15355f
C1160 FS_HIGH_P FS_N_GATE 0.04466f
C1161 PULLUP_P_OUT TERM_OR_P_S 0.38773f
C1162 TERM_OR_P_PLS TERM_OR_P_B 1.1252f
C1163 HS_P_10 HS_PBIAS 2.4508f
C1164 TERM_N_R FS_N_OUT 0.38952f
C1165 PULLDOWN_N_R TERM_GATE_N_BLEED_2 0.05831f
C1166 PULLUP_P_GATE HS_N_1 0.04887f
C1167 FS_P_BLEED_1 PULLUP_N_OUT 0.22595f
C1168 FS_HIGH_P HS_N_11 0.08818f
C1169 HS_P_2 FS_P_OUT 0.10211f
C1170 HS_N_5 HS_N 4.65354f
C1171 TERM_GATE_P HS_N_12 0.10629f
C1172 TERM_N_R PULLUP_N 0.21857f
C1173 HS_P_9 TERM_GATE_P 0.21851f
C1174 TERM_GATE_P_BLEED_0 HS_P_4 0
C1175 HS_P_1 HS_N_12 0.03489f
C1176 HS_N_9 HS_PBIAS 3.54051f
C1177 PULLDOWN_N_R PULLUP_N_BLEED_1 0.05302f
C1178 TERM_N_R LS_SLOW_B 69.0115f
C1179 PULLDOWN_N_R FS_P_OUT 0.84662f
C1180 HS_N PULLUP_N_GATE 0.19163f
C1181 PULLUP_N_BLEED_2 PULLUP_N_WELL 0.00553f
C1182 PULLUP_N_OUT TERM_GATE_P_BLEED_1 0
C1183 TERM_P_R HS_N_7 0.13079f
C1184 HS_N_8 HS_N 2.60585f
C1185 HS_N_9 FS_P_BLEED_6 0.05994f
C1186 LS_SLOW_B FS_PB_BLEED_3 0.83369f
C1187 FS_P_OUT PAD_N 1.97356f
C1188 HS_P_10 HS_P_11 62.4228f
C1189 TRIM_P_0_R TERM_OR_P_B 0.05994f
C1190 TERM_GATE_P_BLEED_1 HS_P_3 0.03192f
C1191 VCM_LOW_OK PULLUP_P_GATE 0.23214f
C1192 HS_N_4 TERM_OR_N_NS 0.00196f
C1193 HS_P PULLUP_P_GATE 0.05979f
C1194 HS_P_4 HS_P_0 0.03097f
C1195 HS_N_5 PULLUP_P 0
C1196 FS_N_CONTROL_S FS_N_GATE 0.91738f
C1197 TERM_OR_N_B HS_N_4 0.04808f
C1198 HS_N_9 HS_P_11 0.03103f
C1199 TERM_GATE_P_BLEED_0 HS_N_5 0.0458f
C1200 PULLUP_P FS_N_BLEED_2 0.82704f
C1201 PULLUP_N_GATE PULLUP_P 0.25778f
C1202 TERM_TRIM2 DIV_ENABLE 0.14201f
C1203 FS_PB_BLEED_5 TERM_P_R 0.05771f
C1204 PAD_P TRIM_N_2_R 0.15454f
C1205 DIV_N TERM_TRIM1 0.0183f
C1206 FS_P_GATE HS_N_7 0.23845f
C1207 HS_N_8 PULLUP_P 0.05062f
C1208 TERM_OR_P_S HS_N_7 0.02404f
C1209 TERM_P_R PULLUP_N_WELL 0.26822f
C1210 TERM_ENABLE FS_NB_BLEED_6 0.07186f
C1211 TERM_GATE_P_BLEED_0 HS_N_8 0.05643f
C1212 HS_P_12 VDD 6.05045f
C1213 HS_N_0 TRIM_N_0_R 0.03489f
C1214 TERM_N_R PULLUP_P_WELL 0.33745f
C1215 HS_N_4 HS_N_2 0.00206f
C1216 FS_NB_GATE TERM_TRIM1 0.70191f
C1217 TERM_TRIM1 HS_N_1 0.05282f
C1218 HS_N_4 PULLUP_P_BLEED_0 0.03931f
C1219 HS_N_9 FS_P_BLEED_4 0.03931f
C1220 HS_P_0 HS_N_5 0.03733f
C1221 PULLUP_P_WELL FS_PB_BLEED_3 0
C1222 TERM_TRIM2 TRIM_P_0_R 0.05219f
C1223 HS_P_12 TRIM_N_1_R 0.02404f
C1224 FS_LOW_P DIV_P 3.54824f
C1225 HS_P_7 LS_SLOW 0.07769f
C1226 HS_P_7 HS_P_5 0.06828f
C1227 HS_P_10 PULLDOWN_P_R 0.02404f
C1228 HS_P_0 HS_N_8 0.03511f
C1229 HS_N_0 HS_N_10 2.19009f
C1230 FS_P_WELL BYPASS_ENABLE 0.06453f
C1231 FS_P_BLEED_0 HS_N_9 0.00105f
C1232 TERM_ENABLE TERM_N_R 0.71377f
C1233 TERM_VCM PULLDOWN_N 0.04828f
C1234 FS_PB_GATE FS_PB_BLEED_0 0.00131f
C1235 DIV_P DIV_ENABLE 6.27105f
C1236 FS_NB_BLEED_3 LS_SLOW 0.06917f
C1237 PAD_P HS_N 1.28043f
C1238 TERM_GATE_N HS_N_4 0.14631f
C1239 HS_N_9 FS_N_OUT 0.06167f
C1240 FS_PB_GATE PULLUP_N_OUT 0.70425f
C1241 FS_N_WELL LS_SLOW 19.9279f
C1242 HS_P_0 RX_P 0
C1243 TERM_ENABLE FS_PB_BLEED_3 0.16736f
C1244 FS_HIGH_P FS_N_BLEED_5 0.09258f
C1245 HS_N_0 HS_N_11 0.03964f
C1246 HS_N_9 PULLDOWN_P_R 0.05893f
C1247 VCM_LOW_OK TERM_TRIM1 0.06532f
C1248 PULLUP_P_OUT HS_P_7 0.05519f
C1249 HS_P TERM_TRIM1 0.0264f
C1250 LS_SLOW DIV_LOW_N 0.06034f
C1251 LS_SLOW TERM_TRIM0 0.09564f
C1252 TERM_TRIM0 HS_P_5 0.02404f
C1253 DIV_P TRIM_P_0_R 0.06521f
C1254 HS_P_4 TERM_GATE_P 0.15514f
C1255 PULLDOWN_P_R PULLUP_P_BLEED_4 0.00488f
C1256 HS_P_1 HS_P_4 0
C1257 HS_P_6 HS_P_12 0.03881f
C1258 TERM_OR_N_B TERM_VCM 0.09944f
C1259 PULLUP_N_OUT HS_P_3 0.02866f
C1260 PULLUP_P_GATE VDD 9.93388f
C1261 TERM_LSA_GATE_N TERM_TRIM0 0.16264f
C1262 PULLUP_P_OUT TERM_TRIM0 0.0806f
C1263 DIV_N FS_PB_BLEED_6 0
C1264 LS_SLOW TERM_LSA_GATE_P 0.10257f
C1265 TERM_LSA_GATE_P HS_P_5 0.05893f
C1266 LS_SLOW TERM_GATE_P_BLEED_2 0.06827f
C1267 PULLUP_P_BLEED_2 HS_N_4 0.04421f
C1268 TRIM_N_1_R PULLUP_P_GATE 0.08377f
C1269 TERM_VCM HS_N_2 0.24038f
C1270 HS_N_5 TERM_GATE_P 0.10618f
C1271 FS_PB_BLEED_6 HS_N_1 0
C1272 DIV_LOW_P HS_PBIAS 0.0082f
C1273 TERM_VCM PULLUP_P_BLEED_0 0.03472f
C1274 TERM_N_R HS_N_6 0.05893f
C1275 TERM_OR_N_B TRIM_N_2_R 0.04346f
C1276 HS_P_1 HS_N_5 0.06578f
C1277 PULLDOWN_P DIFF_ENABLE 0.11011f
C1278 VCM_LOW_OK TRIM_P_1_R 0.04128f
C1279 PULLUP_N_OUT FS_HIGH_N 0.09451f
C1280 FS_HIGH_P HS_N_4 0.08792f
C1281 HS_P TRIM_P_1_R 0.00754f
C1282 FS_PB_GATE HS_N_13 0.29305f
C1283 PAD_P HS_P_0 1.77945f
C1284 FS_N_BLEED_3 TERM_TRIM1 0.01524f
C1285 HS_N_8 TERM_GATE_P 0.10799f
C1286 PULLUP_P_OUT TERM_LSA_GATE_P 1.0304f
C1287 HS_N_9 PULLUP_P_WELL 0.14999f
C1288 PULLUP_P_OUT TERM_GATE_P_BLEED_2 0.05319f
C1289 HS_P_2 TERM_P_R 0.1198f
C1290 HS_P_7 HS_N_7 0
C1291 HS_P_1 HS_N_8 0.06335f
C1292 FS_PB_CONTROL_LS VDD 0.75225f
C1293 HS_P_12 HS_N_12 0.04783f
C1294 TERM_ENABLE HS_P_10 0.03357f
C1295 FS_PB_BLEED_0 HS_N_13 0.03931f
C1296 PULLDOWN_N_R TERM_P_R 0.23105f
C1297 HS_P TERM_OR_N_PLS 0
C1298 HS_P_12 HS_P_9 0.02846f
C1299 BYPASS_ENABLE FS_P_BLEED_4 0.00766f
C1300 TERM_GATE_N TERM_VCM 16.5729f
C1301 PULLUP_N_OUT HS_N_13 0.04223f
C1302 TRIM_N_2_R PULLUP_P_BLEED_0 0.04689f
C1303 TERM_P_R PAD_N 0.13957f
C1304 PULLDOWN_P TRIM_N_0_R 0.04783f
C1305 FS_PB_CONTROL_LS TRIM_N_1_R 0.00817f
C1306 LS_SLOW TERM_OR_P_NS 0.0586f
C1307 HS_N_9 TERM_ENABLE 0.02536f
C1308 HS_N_13 HS_P_3 0.02464f
C1309 FS_P_WELL TRIM_N_0_R 0.80019f
C1310 TRIM_N_0_R HS_P_13 0.02476f
C1311 FS_PB_GATE FS_P_BLEED_5 0.00257f
C1312 HS_P_10 HS_P_8 0.04808f
C1313 HS_PBIAS DIFF_ENABLE 0.1887f
C1314 PULLUP_P PULLDOWN_N 0.06058f
C1315 TERM_TRIM0 HS_N_7 0.07211f
C1316 TERM_TRIM1 VDD 4.34013f
C1317 TERM_OR_N_B HS_N 0.11235f
C1318 PAD_P TRIM_P_2_R 0.41302f
C1319 TERM_VCM FS_PB_BLEED_4 0.05612f
C1320 TERM_OR_P_S HS_P_2 0.02404f
C1321 PULLUP_P_GATE HS_N_3 0.04808f
C1322 DIV_N RX_N 1.36638f
C1323 PULLUP_P_OUT TERM_OR_P_NS 0.05458f
C1324 TERM_ENABLE PULLUP_P_BLEED_4 0.01311f
C1325 TERM_OR_P_B HS_P_5 0.0831f
C1326 LS_SLOW TERM_OR_P_B 2.10594f
C1327 PULLDOWN_P HS_N_10 0.02404f
C1328 PULLDOWN_N_R FS_P_GATE 0.59287f
C1329 DIV_N HS_N_1 0.04359f
C1330 TERM_GATE_N TRIM_N_2_R 0.04279f
C1331 FS_PB_GATE FS_P_OUT 28.0518f
C1332 FS_N_WELL FS_N_BLEED_1 0.85999f
C1333 TRIM_N_1_R TERM_TRIM1 6.67315f
C1334 PULLDOWN_P FS_N_GATE 10.4198f
C1335 TERM_OR_P_S PULLDOWN_N_R 0.04128f
C1336 PULLUP_N_OUT TERM_GATE_N_BLEED_2 0
C1337 PULLDOWN_P FS_NB_BLEED_2 0.26852f
C1338 HS_N_9 HS_P_8 0.1392f
C1339 PULLUP_N_BLEED_0 PULLUP_N_WELL 0.04549f
C1340 FS_NB_BLEED_3 PULLUP_N_WELL 0
C1341 FS_P_WELL HS_N_10 1.11749f
C1342 FS_P_BLEED_3 VDD 0.7956f
C1343 PULLDOWN_P HS_N_11 0.02404f
C1344 HS_N_2 HS_N 6.79185f
C1345 TERM_GATE_N_BLEED_0 FS_N_OUT 0.35543f
C1346 TRIM_N_0_R HS_PBIAS 0.14331f
C1347 HS_N PULLUP_P_BLEED_0 0.05271f
C1348 TERM_OR_N_NS PULLUP_P 0
C1349 TERM_LSA_GATE_P HS_N_7 0.05893f
C1350 PULLUP_N_OUT PULLUP_N_BLEED_1 0.00305f
C1351 PULLUP_P_OUT TERM_OR_P_B 0.26013f
C1352 PULLUP_N_OUT FS_P_OUT 0.53047f
C1353 FS_PB_BLEED_5 TERM_TRIM0 0.04477f
C1354 FS_P_WELL HS_N_11 1.06306f
C1355 TERM_OR_N_B PULLUP_P 0.22351f
C1356 FS_PB_BLEED_4 TRIM_N_2_R 0.17234f
C1357 TRIM_N_1_R FS_P_BLEED_3 0.04016f
C1358 HS_P_10 HS_N_6 0.03097f
C1359 PULLUP_N_WELL TERM_TRIM0 0.25661f
C1360 FS_HIGH_P TERM_VCM 0.28953f
C1361 FS_P_OUT HS_P_3 0.09146f
C1362 PULLUP_P_GATE HS_N_12 0.04845f
C1363 DIV_N VCM_LOW_OK 0.00178f
C1364 DIV_N HS_P 0.04488f
C1365 HS_P_1 PAD_P 1.31611f
C1366 DIV_LOW_P LS_SLOW_B 0.82462f
C1367 HS_PBIAS HS_N_10 1.07528f
C1368 HS_N_9 HS_N_6 0.04101f
C1369 TERM_GATE_N HS_N 0.28339f
C1370 LS_SLOW TERM_TRIM2 0.12858f
C1371 FS_N_GATE HS_PBIAS 0.95629f
C1372 TRIM_P_1_R VDD 0.26802f
C1373 HS_N_0 HS_N_4 0.03919f
C1374 FS_LOW_N TERM_TRIM1 0.08488f
C1375 HS_PBIAS FS_NB_BLEED_2 0.01803f
C1376 FS_P_BLEED_6 HS_N_10 0.03823f
C1377 HS_P FS_NB_GATE 0.38189f
C1378 PULLUP_P PULLUP_P_BLEED_0 0.05771f
C1379 VCM_LOW_OK HS_N_1 0.08491f
C1380 HS_P_6 TERM_TRIM1 0.06909f
C1381 HS_P HS_N_1 0.17892f
C1382 TERM_GATE_P_BLEED_0 HS_N_2 0.03931f
C1383 HS_N_11 HS_PBIAS 1.10123f
C1384 TRIM_N_1_R TRIM_P_1_R 0.06998f
C1385 FS_HIGH_N PULLUP_N_BLEED_1 0.16603f
C1386 HS_N_3 TERM_TRIM1 0.02404f
C1387 FS_P_BLEED_6 HS_N_11 0.03807f
C1388 BYPASS_ENABLE PULLUP_P_WELL 0.00823f
C1389 TERM_OR_N_PLS VDD 5.82027f
C1390 FS_HIGH_P TRIM_N_2_R 0.00319f
C1391 m2_42279_124800# a_41005_132385# 0
C1392 TERM_TRIM2 TERM_LSA_GATE_N 0.15717f
C1393 PULLUP_P_OUT TERM_TRIM2 0.12856f
C1394 FS_LOW_P FS_NB_BLEED_6 0.06271f
C1395 HS_P_11 HS_N_10 0.00351f
C1396 HS_P_4 HS_P_12 0
C1397 FS_P_BLEED_4 TRIM_N_0_R 0.04294f
C1398 TERM_GATE_N PULLUP_P 0.17963f
C1399 HS_P_0 HS_N_2 0.03722f
C1400 FS_N_CONTROL_S TERM_VCM 0.05568f
C1401 HS_P_11 HS_N_11 0.06806f
C1402 TERM_P_R TERM_GATE_P_BLEED_1 0.00257f
C1403 TRIM_N_0_R FS_P_BLEED_2 0.00148f
C1404 FS_LOW_P FS_N_BLEED_6 0.05822f
C1405 FS_P_OUT HS_N_13 0.81029f
C1406 TERM_OR_P_B HS_N_7 0.05828f
C1407 VCM_LOW_OK HS_P 0.10197f
C1408 FS_NB_BLEED_6 DIV_ENABLE 0.03564f
C1409 LS_SLOW DIV_P 0.0603f
C1410 DIV_P HS_P_5 0.04218f
C1411 PULLUP_N DIFF_ENABLE 0.15118f
C1412 PULLUP_P_BLEED_2 HS_N 0.22944f
C1413 FS_P_BLEED_4 HS_N_10 0.03931f
C1414 FS_N_BLEED_6 DIV_ENABLE 0
C1415 FS_P_BLEED_1 FS_P_GATE 0.06987f
C1416 HS_N_12 TERM_TRIM1 0.02423f
C1417 TRIM_N_0_R FS_N_OUT 0.06167f
C1418 FS_LOW_P TERM_N_R 0.2234f
C1419 HS_P_7 HS_P_2 0.03116f
C1420 HS_P_12 HS_N_5 0.03089f
C1421 HS_P_9 TERM_TRIM1 0.03494f
C1422 HS_P_6 TRIM_P_1_R 0.04872f
C1423 FS_HIGH_P HS_N 0.14106f
C1424 PULLUP_P_OUT DIV_P 0.02755f
C1425 PULLDOWN_P FS_N_BLEED_5 0.04878f
C1426 FS_P_BLEED_4 HS_N_11 0.03931f
C1427 HS_P_7 PULLDOWN_N_R 0.07217f
C1428 LS_SLOW_B TRIM_N_0_R 0.13825f
C1429 TERM_ENABLE DIV_LOW_P 0.14558f
C1430 TERM_N_R DIV_ENABLE 0.06831f
C1431 HS_P_12 HS_N_8 0.02854f
C1432 TRIM_P_1_R HS_N_3 0
C1433 HS_P_7 PAD_N 0.39087f
C1434 FS_NB_BLEED_3 PULLDOWN_N_R 0.00251f
C1435 HS_N_10 FS_N_OUT 0.01755f
C1436 HS_N_0 TERM_VCM 0.32087f
C1437 PULLDOWN_P_R HS_N_10 0.05925f
C1438 FS_N_GATE FS_N_OUT 20.8964f
C1439 TERM_TRIM2 HS_N_7 0.07975f
C1440 FS_N_WELL PULLDOWN_N_R 1.86841f
C1441 DIV_N VDD 0.3403f
C1442 HS_P_2 TERM_TRIM0 0.02404f
C1443 TERM_N_R TRIM_P_0_R 0.10436f
C1444 HS_N_11 FS_N_OUT 0.01505f
C1445 PULLDOWN_P_R HS_N_11 0.05918f
C1446 PULLDOWN_N_R DIV_LOW_N 0
C1447 FS_NB_GATE FS_NB_BLEED_0 0
C1448 DIV_N TRIM_N_1_R 0.08319f
C1449 FS_NB_GATE VDD 29.4489f
C1450 LS_SLOW_B FS_N_GATE 0.35098f
C1451 VDD HS_N_1 5.71655f
C1452 PULLDOWN_N_R TERM_TRIM0 0.1096f
C1453 HS_PBIAS FS_N_BLEED_5 0.05271f
C1454 PULLUP_N_BLEED_5 PULLUP_N_GATE 0.37243f
C1455 HS_N_2 TERM_GATE_P 0.10547f
C1456 HS_N_0 TRIM_N_2_R 0.01458f
C1457 TRIM_N_1_R HS_N_1 0.05049f
C1458 HS_P_1 HS_N_2 0.13287f
C1459 HS_P_9 TRIM_P_1_R 0.059f
C1460 FS_PB_GATE TERM_P_R 0.46579f
C1461 FS_PB_BLEED_5 TERM_TRIM2 0.04294f
C1462 HS_P_2 TERM_LSA_GATE_P 0.05893f
C1463 TERM_ENABLE DIFF_ENABLE 0.04714f
C1464 TRIM_N_0_R PULLUP_P_WELL 0.19647f
C1465 FS_HIGH_P FS_PB_CONTROL_S 0.40956f
C1466 PULLDOWN_P HS_N_4 0.02404f
C1467 TERM_TRIM2 PULLUP_N_WELL 0.20135f
C1468 FS_P_CONTROL_S TERM_TRIM1 0.049f
C1469 DIV_P HS_N_7 0.04369f
C1470 FS_NB_GATE FS_NB_BLEED_1 0
C1471 PULLDOWN_N_R TERM_LSA_GATE_P 0.09341f
C1472 HS_N_5 PULLUP_P_GATE 0.05072f
C1473 PULLDOWN_N_R TERM_GATE_P_BLEED_2 0.00251f
C1474 FS_P_WELL HS_N_4 0.97217f
C1475 PULLUP_N_OUT TERM_P_R 0.3221f
C1476 FS_PB_BLEED_6 HS_N_12 0
C1477 PULLUP_N_BLEED_2 FS_HIGH_N 0.00933f
C1478 HS_P VDD 1.43519f
C1479 VCM_LOW_OK VDD 3.98833f
C1480 HS_N_4 HS_P_13 0.00553f
C1481 FS_LOW_P HS_P_10 0.08684f
C1482 FS_NB_BLEED_5 TERM_VCM 0.13629f
C1483 DIV_N FS_LOW_N 0.0445f
C1484 HS_N_8 PULLUP_P_GATE 0.0541f
C1485 PULLUP_P_WELL HS_N_10 0.14115f
C1486 TERM_P_R HS_P_3 0.11927f
C1487 HS_P_6 DIV_N 0
C1488 TERM_ENABLE TRIM_N_0_R 0.06594f
C1489 ESD_RAIL a_41852_148519# 0.33756p
C1490 a_44789_117064# a_41005_131545# 0.02926f
C1491 HS_P_12 PAD_P 1.73933f
C1492 TRIM_N_1_R HS_P 0.05441f
C1493 VCM_LOW_OK TRIM_N_1_R 0.02404f
C1494 FS_PB_GATE FS_P_GATE 0.71159f
C1495 LS_SLOW_B PULLUP_P_BLEED_5 0.83369f
C1496 HS_P_10 DIV_ENABLE 0.03996f
C1497 HS_N_9 FS_LOW_P 0.21712f
C1498 FS_NB_GATE FS_LOW_N 0.55501f
C1499 HS_N_0 HS_N 0.16601p
C1500 DIV_N HS_N_3 0.04261f
C1501 FS_NB_CONTROL_LS FS_NB_GATE 0.33895f
C1502 FS_LOW_N HS_N_1 0.08505f
C1503 PULLUP_P_WELL HS_N_11 0.13238f
C1504 HS_P_6 HS_N_1 0.03425f
C1505 FS_N_WELL FS_N_BLEED_0 0.20845f
C1506 HS_P FS_NB_BLEED_1 0.1239f
C1507 HS_P_4 TERM_TRIM1 0.02412f
C1508 HS_N_4 HS_PBIAS 1.07268f
C1509 PULLUP_N_OUT FS_P_GATE 0.47684f
C1510 PULLUP_P_CONTROL_S PULLUP_P 1.51438f
C1511 HS_N_9 DIV_ENABLE 0.08392f
C1512 TERM_OR_P_S PULLUP_N_OUT 0.32321f
C1513 TERM_ENABLE HS_N_10 0.02431f
C1514 FS_P_BLEED_6 HS_N_4 0.04228f
C1515 HS_N_3 HS_N_1 0.08226f
C1516 PULLDOWN_N_R TERM_OR_P_NS 0.00267f
C1517 TERM_P_R FS_HIGH_N 0.04417f
C1518 HS_P_10 TRIM_P_0_R 0.04808f
C1519 TERM_ENABLE FS_N_GATE 0.49239f
C1520 HS_P_2 TERM_OR_P_B 0.08427f
C1521 TERM_OR_P_S HS_P_3 0.02404f
C1522 TERM_ENABLE HS_N_11 0.02427f
C1523 HS_P_7 TERM_GATE_P_BLEED_1 0.03089f
C1524 HS_N_0 PULLUP_P 0.05062f
C1525 VCM_LOW_OK FS_LOW_N 0.20301f
C1526 HS_N_9 TRIM_P_0_R 0.04808f
C1527 HS_P FS_LOW_N 0.08596f
C1528 HS_N_4 HS_P_11 0.06606f
C1529 HS_N_5 TERM_TRIM1 0.02462f
C1530 PULLDOWN_N_R TERM_OR_P_B 0.13432f
C1531 DIV_N HS_N_12 0.04218f
C1532 HS_P_8 HS_N_10 0.03489f
C1533 TERM_P_R HS_N_13 0.09441f
C1534 HS_P_6 HS_P 3.44199f
C1535 HS_P_6 VCM_LOW_OK 0.13109f
C1536 TERM_GATE_P_BLEED_0 HS_N_0 0.04051f
C1537 LS_SLOW_B FS_N_BLEED_5 0.06383f
C1538 PULLDOWN_P TERM_VCM 0.22621f
C1539 PULLUP_N_GATE TERM_TRIM1 0.31735f
C1540 PULLUP_N_BLEED_2 PULLUP_N_BLEED_1 0.96553f
C1541 VCM_LOW_OK HS_N_3 0.08296f
C1542 HS_P HS_N_3 0.17867f
C1543 HS_N_8 TERM_TRIM1 0.05374f
C1544 HS_P_8 HS_N_11 0.03489f
C1545 HS_N_6 TRIM_N_0_R 0.03489f
C1546 HS_N_12 HS_N_1 0.07584f
C1547 HS_P_9 HS_N_1 0.02599f
C1548 FS_P_WELL TERM_VCM 0.86527f
C1549 TERM_VCM HS_P_13 0.24435f
C1550 LS_SLOW FS_NB_CONTROL_S 0.02694f
C1551 HS_P_4 TRIM_P_1_R 0.04942f
C1552 HS_N_0 HS_P_0 0.04061f
C1553 HS_N_4 FS_P_BLEED_4 0.03931f
C1554 TERM_ENABLE PULLUP_P_BLEED_5 0.16736f
C1555 FS_P_GATE HS_N_13 0.23446f
C1556 HS_N_6 HS_N_10 0
C1557 TERM_OR_P_S HS_N_13 0.02404f
C1558 PULLDOWN_P TRIM_N_2_R 0.03698f
C1559 PULLDOWN_N_R TERM_TRIM2 0.07472f
C1560 LS_SLOW FS_NB_BLEED_6 0.06707f
C1561 TRIM_N_1_R VDD 2.6359f
C1562 TERM_LSA_GATE_P TERM_GATE_P_BLEED_1 0.00116f
C1563 VCM_LOW_OK HS_N_12 0.08374f
C1564 TERM_P_R PULLUP_N_BLEED_1 0.05801f
C1565 HS_P HS_N_12 0.78592f
C1566 FS_P_WELL TRIM_N_2_R 0.73212f
C1567 TERM_P_R FS_P_OUT 0.44722f
C1568 HS_N_6 HS_N_11 0
C1569 TERM_GATE_P_BLEED_1 TERM_GATE_P_BLEED_2 0.26304f
C1570 TERM_VCM HS_PBIAS 0.7891f
C1571 TRIM_N_2_R HS_P_13 0.00509f
C1572 VCM_LOW_OK HS_P_9 0.11584f
C1573 HS_P HS_P_9 6.36939f
C1574 HS_N_5 TRIM_P_1_R 0
C1575 PULLDOWN_P_R HS_N_4 0.05893f
C1576 PULLUP_N_BLEED_5 PULLDOWN_N 0.0078f
C1577 FS_NB_BLEED_1 FS_NB_BLEED_0 0.06543f
C1578 HS_N_8 TRIM_P_1_R 0
C1579 PULLUP_P_BLEED_3 PULLUP_P_GATE 0
C1580 HS_P_2 DIV_P 0.04218f
C1581 LS_SLOW TERM_N_R 0.57945f
C1582 HS_P_12 HS_N_2 0.03089f
C1583 TERM_VCM HS_P_11 0.21835f
C1584 BYPASS_ENABLE DIV_ENABLE 89.8435f
C1585 HS_PBIAS TRIM_N_2_R 0.20624f
C1586 PULLDOWN_P HS_N 0.03743f
C1587 FS_LOW_P TERM_GATE_N_BLEED_0 0.11702f
C1588 HS_N_8 TERM_OR_N_PLS 0
C1589 PULLDOWN_N_R DIV_P 0.07241f
C1590 HS_P_7 PULLUP_N_OUT 0.0846f
C1591 FS_P_GATE FS_P_OUT 19.2027f
C1592 TERM_ENABLE FS_N_BLEED_5 0.0714f
C1593 TERM_OR_P_S FS_P_OUT 0.04377f
C1594 FS_LOW_N VDD 0.99401f
C1595 FS_LOW_N FS_NB_BLEED_0 0.08377f
C1596 DIV_P PAD_N 0.47479f
C1597 FS_P_WELL HS_N 1.59221f
C1598 FS_NB_CONTROL_LS VDD 0.64966f
C1599 HS_P_6 VDD 6.03631f
C1600 TERM_N_R TERM_LSA_GATE_N 5.95489f
C1601 FS_NB_BLEED_3 PULLUP_N_OUT 0.05095f
C1602 HS_N HS_P_13 0.30024f
C1603 FS_PB_GATE TERM_TRIM0 0.37494f
C1604 PULLUP_P_OUT TERM_N_R 0.10136f
C1605 HS_P_7 HS_P_3 0.03129f
C1606 DIV_ENABLE TERM_GATE_N_BLEED_0 0
C1607 BYPASS_ENABLE TRIM_P_0_R 0
C1608 HS_N_0 TERM_GATE_P 0.10943f
C1609 PULLUP_N_OUT FS_N_WELL 2.18756f
C1610 FS_NB_BLEED_4 TERM_VCM 0.00196f
C1611 TRIM_N_1_R FS_LOW_N 0.00307f
C1612 PULLUP_P_OUT FS_PB_BLEED_3 0.05628f
C1613 HS_N_3 VDD 5.22459f
C1614 TERM_VCM FS_P_BLEED_4 0.04294f
C1615 DIV_LOW_P DIV_ENABLE 1.67013f
C1616 HS_P_6 TRIM_N_1_R 0.03147f
C1617 HS_P_1 HS_N_0 0.03489f
C1618 PULLUP_N_OUT DIV_LOW_N 0.04729f
C1619 TERM_VCM FS_P_BLEED_2 0.00196f
C1620 PULLUP_N_OUT TERM_TRIM0 0.11556f
C1621 HS_N_4 PULLUP_P_WELL 0.12315f
C1622 TRIM_N_1_R HS_N_3 0.04811f
C1623 HS_N HS_PBIAS 0.40212f
C1624 TERM_TRIM0 HS_P_3 0.02404f
C1625 DIV_LOW_P TRIM_P_0_R 0.00611f
C1626 FS_P_BLEED_6 HS_N 0.22766f
C1627 TERM_GATE_P_BLEED_0 HS_P_13 0
C1628 TERM_VCM FS_N_OUT 0.6424f
C1629 PULLDOWN_P_R TERM_VCM 0.33763f
C1630 FS_P_BLEED_4 TRIM_N_2_R 0.05336f
C1631 DIV_N HS_N_5 0.04218f
C1632 FS_LOW_P DIFF_ENABLE 0.22748f
C1633 FS_N_WELL FS_HIGH_N 8.88811f
C1634 HS_N_12 VDD 6.42775f
C1635 PULLUP_N_OUT TERM_LSA_GATE_P 0.8182f
C1636 PAD_P TRIM_P_1_R 1.4205f
C1637 TERM_ENABLE HS_N_4 0.02404f
C1638 FS_P_BLEED_2 TRIM_N_2_R 0
C1639 PULLUP_N_OUT TERM_GATE_P_BLEED_2 0.22623f
C1640 PULLUP_P_GATE HS_N_2 0.04808f
C1641 HS_P_9 VDD 7.41304f
C1642 TERM_VCM LS_SLOW_B 0.93086f
C1643 PULLUP_P_GATE PULLUP_P_BLEED_0 0.05949f
C1644 DIV_N HS_N_8 0.04218f
C1645 FS_P_WELL FS_PB_CONTROL_S 0.06051f
C1646 HS_P_11 HS_N 0.6688f
C1647 HS_N_5 HS_N_1 0.04302f
C1648 HS_P_4 VCM_LOW_OK 0.14931f
C1649 TERM_LSA_GATE_P HS_P_3 0.05893f
C1650 TRIM_N_1_R HS_N_12 0.0491f
C1651 HS_PBIAS PULLUP_P 0.31274f
C1652 DIV_ENABLE DIFF_ENABLE 6.75693f
C1653 TERM_TRIM1 PULLDOWN_N 0.03489f
C1654 HS_P_4 HS_P 1.7567f
C1655 TERM_TRIM0 FS_HIGH_N 0.02404f
C1656 LS_SLOW HS_P_10 0.03478f
C1657 HS_P_10 HS_P_5 0
C1658 HS_P_0 HS_P_13 0.04439f
C1659 FS_NB_GATE FS_N_BLEED_2 0.07498f
C1660 FS_NB_GATE PULLUP_N_GATE 0.06813f
C1661 TRIM_N_1_R HS_P_9 0.02404f
C1662 TERM_N_R HS_N_7 0.10224f
C1663 FS_LOW_N HS_N_3 0.08505f
C1664 FS_N_WELL HS_N_13 0.02051f
C1665 DIV_N RX_P 0.72665f
C1666 HS_P_8 HS_N_4 0.03489f
C1667 HS_P_6 HS_N_3 0.03425f
C1668 PULLDOWN_P_R TRIM_N_2_R 0.01596f
C1669 HS_N_8 HS_N_1 0.04294f
C1670 FS_NB_BLEED_6 PULLUP_N_WELL 0.04408f
C1671 FS_LOW_P TRIM_N_0_R 0.10913f
C1672 TERM_P_R PULLUP_N_BLEED_2 0.00257f
C1673 HS_N_9 HS_P_5 0.03089f
C1674 HS_N_9 LS_SLOW 0.02822f
C1675 RX_P RX_N 20.1628f
C1676 HS_N_13 TERM_TRIM0 0.04808f
C1677 LS_SLOW_B TRIM_N_2_R 0.07683f
C1678 FS_P_BLEED_4 HS_N 0.05271f
C1679 TRIM_N_0_R DIV_ENABLE 0.03849f
C1680 VCM_LOW_OK HS_N_5 0.08296f
C1681 PULLUP_N_OUT TERM_OR_P_NS 0.18347f
C1682 HS_P_0 HS_PBIAS 7.54835f
C1683 HS_P HS_N_5 0.87187f
C1684 TERM_OR_N_B TERM_TRIM1 0.1481f
C1685 TERM_GATE_P_BLEED_0 HS_P_11 0.00863f
C1686 TERM_N_R FS_PB_BLEED_5 0.06307f
C1687 LS_SLOW PULLUP_P_BLEED_4 0.07023f
C1688 FS_LOW_P HS_N_10 0.08963f
C1689 PULLUP_P_OUT HS_N_9 0.03516f
C1690 FS_LOW_P FS_N_GATE 0.27991f
C1691 TERM_OR_N_S TERM_P_R 0.77987f
C1692 HS_P PULLUP_N_GATE 0.1185f
C1693 TERM_N_R PULLUP_N_WELL 0.29402f
C1694 TERM_VCM PULLUP_P_WELL 0.19981f
C1695 FS_LOW_N HS_N_12 0.08505f
C1696 FS_PB_BLEED_5 FS_PB_BLEED_3 0.25341f
C1697 VCM_LOW_OK HS_N_8 0.08296f
C1698 HS_P HS_N_8 0.59635f
C1699 HS_P_6 HS_N_12 0.03425f
C1700 PULLUP_N_BLEED_0 PULLUP_N_BLEED_1 0.97237f
C1701 HS_N_6 HS_N_4 0.07075f
C1702 TERM_LSA_GATE_P HS_N_13 0.05893f
C1703 FS_LOW_P HS_N_11 0.08963f
C1704 TRIM_N_0_R TRIM_P_0_R 0.26813f
C1705 HS_N FS_N_OUT 1.63864f
C1706 DIV_ENABLE HS_N_10 0.08392f
C1707 HS_P_6 HS_P_9 0.04232f
C1708 PULLUP_N_OUT TERM_OR_P_B 3.24828f
C1709 PULLDOWN_P_R HS_N 0.09216f
C1710 HS_N_2 TERM_TRIM1 0.02404f
C1711 FS_N_GATE DIV_ENABLE 0.00182f
C1712 HS_N_3 HS_N_12 0.06413f
C1713 FS_P_CONTROL_S VDD 2.01626f
C1714 TERM_TRIM1 PULLUP_P_BLEED_0 0.03472f
C1715 HS_P_0 HS_P_11 0.03142f
C1716 FS_PB_BLEED_2 VCM_LOW_OK 0.02372f
C1717 PULLDOWN_N_R PULLUP_N_BLEED_6 0.036f
C1718 HS_P_9 HS_N_3 0.02404f
C1719 HS_N_11 DIV_ENABLE 0.08392f
C1720 TERM_OR_P_B HS_P_3 0.08374f
C1721 TERM_ENABLE TERM_VCM 1.04627f
C1722 TERM_TRIM0 PULLUP_N_BLEED_1 0.04507f
C1723 PULLUP_P_BLEED_2 PULLUP_P_GATE 0.00149f
C1724 TRIM_N_1_R FS_P_CONTROL_S 0.03551f
C1725 FS_P_OUT TERM_TRIM0 0.24279f
C1726 DIV_N PAD_P 0.48137f
C1727 TRIM_P_2_R HS_PBIAS 0.00733f
C1728 ESD_RAIL a_41005_132385# 0.53823f
C1729 PULLUP_P_WELL TRIM_N_2_R 0.15491f
C1730 a_43813_117064# a_41005_131545# 2.44008f
C1731 TRIM_P_0_R HS_N_10 0.04949f
C1732 FS_PB_GATE TERM_TRIM2 0.25214f
C1733 TERM_GATE_P HS_P_13 0.15793f
C1734 PULLUP_N_CONTROL_S PULLUP_P 0
C1735 PULLUP_P FS_N_OUT 0.46697f
C1736 FS_HIGH_P PULLUP_P_GATE 0.02645f
C1737 PAD_P RX_N 0.47227f
C1738 FS_P_GATE TERM_P_R 0.30114f
C1739 HS_P_1 HS_P_13 0.08959f
C1740 HS_P_10 HS_N_7 0
C1741 PULLDOWN_P_R PULLUP_P 0.00144f
C1742 TERM_GATE_N TERM_TRIM1 0.1751f
C1743 PAD_P HS_N_1 0.51703f
C1744 HS_N_11 TRIM_P_0_R 0.04911f
C1745 TERM_OR_P_S TERM_P_R 0.11189f
C1746 HS_P_8 TERM_VCM 0.19342f
C1747 HS_P_4 VDD 5.225f
C1748 PULLUP_N_OUT TERM_TRIM2 0.11676f
C1749 LS_SLOW_B PULLUP_P 0.04417f
C1750 TERM_ENABLE TRIM_N_2_R 0.05267f
C1751 FS_P_OUT TERM_LSA_GATE_P 0.09838f
C1752 HS_P_9 HS_N_12 0.02482f
C1753 FS_N_BLEED_3 FS_N_BLEED_2 0.03688f
C1754 HS_N_9 HS_N_7 0.04151f
C1755 PULLDOWN_N_R FS_NB_CONTROL_S 0.04229f
C1756 TERM_OR_N_B TERM_OR_N_PLS 0.30225f
C1757 HS_P_4 TRIM_N_1_R 0.02404f
C1758 HS_P_12 HS_N_0 0.04058f
C1759 TERM_GATE_P HS_PBIAS 0.02057f
C1760 FS_PB_BLEED_4 TERM_TRIM1 0.12499f
C1761 TRIM_P_1_R HS_N_2 0
C1762 TERM_N_R TERM_GATE_N_BLEED_1 0.00257f
C1763 PULLDOWN_P_R FS_PB_CONTROL_S 0.02198f
C1764 HS_P_1 HS_PBIAS 4.11478f
C1765 HS_N_13 TERM_OR_P_B 0.05828f
C1766 HS_N PULLUP_P_WELL 0.30184f
C1767 HS_P_0 PULLDOWN_P_R 0.07393f
C1768 HS_P PAD_P 39.9075f
C1769 HS_P_8 TRIM_N_2_R 0
C1770 LS_SLOW_B FS_PB_CONTROL_S 0.5138f
C1771 PULLDOWN_N_R FS_NB_BLEED_6 0.04859f
C1772 HS_N_5 VDD 6.26429f
C1773 HS_P_0 LS_SLOW_B 0.05016f
C1774 HS_N_6 TERM_VCM 0.25413f
C1775 HS_N_9 FS_PB_BLEED_5 0.03931f
C1776 PULLUP_N_GATE VDD 11.0569f
C1777 HS_P_11 TERM_GATE_P 0.18393f
C1778 PULLUP_N_OUT DIV_P 0.05836f
C1779 TERM_TRIM2 FS_HIGH_N 0.02404f
C1780 TRIM_N_1_R HS_N_5 0.04808f
C1781 HS_N_8 VDD 6.08215f
C1782 HS_P_1 HS_P_11 0.03192f
C1783 TERM_ENABLE HS_N 0.04684f
C1784 FS_LOW_P FS_N_BLEED_5 0.06233f
C1785 PULLUP_P_WELL PULLUP_P 0.27888f
C1786 FS_HIGH_P TERM_TRIM1 0.10631f
C1787 DIV_P HS_P_3 0.04218f
C1788 TRIM_N_1_R HS_N_8 0.04808f
C1789 HS_P_6 HS_P_4 0.07175f
C1790 PULLDOWN_P_R TRIM_P_2_R 0
C1791 PULLUP_P_CONTROL_S PULLUP_P_GATE 0.41117f
C1792 TERM_GATE_N TERM_OR_N_PLS 2.88097f
C1793 PULLDOWN_N_R TERM_N_R 0.1807f
C1794 DIV_ENABLE FS_N_BLEED_5 0.03564f
C1795 HS_P_8 HS_N 0.23138f
C1796 FS_P_OUT TERM_OR_P_B 0.11136f
C1797 TERM_N_R PAD_N 0.59257f
C1798 PULLUP_P_BLEED_3 VCM_LOW_OK 0.93103f
C1799 PULLUP_P_BLEED_3 HS_P 0.00212f
C1800 LS_SLOW_B TRIM_P_2_R 0.14312f
C1801 DIV_N TERM_OR_N_B 0.00135f
C1802 PULLUP_P_OUT DIV_LOW_P 0.02561f
C1803 TERM_ENABLE PULLUP_P 0.04819f
C1804 HS_N_0 PULLUP_P_GATE 0.04905f
C1805 HS_N_5 FS_LOW_N 0.08533f
C1806 HS_P_6 HS_N_5 0.03425f
C1807 TERM_OR_N_B HS_N_1 0.05002f
C1808 TERM_GATE_P FS_N_OUT 0.06408f
C1809 FS_LOW_N PULLUP_N_GATE 0.12101f
C1810 FS_N_CONTROL_S TERM_TRIM1 0.04905f
C1811 m2_42279_124800# a_41005_131825# 0
C1812 PULLDOWN_P_R TERM_GATE_P 0.23822f
C1813 HS_N_8 FS_LOW_N 0.08561f
C1814 DIV_N HS_N_2 0.04218f
C1815 HS_P_1 FS_N_OUT 0.06167f
C1816 HS_P_7 TERM_P_R 0.15972f
C1817 HS_N_5 HS_N_3 0.00206f
C1818 DIV_N PULLUP_P_BLEED_0 0.10151f
C1819 HS_P_1 PULLDOWN_P_R 0.02404f
C1820 LS_SLOW DIFF_ENABLE 0.10866f
C1821 HS_P_6 HS_N_8 0.02404f
C1822 DIV_P HS_N_13 0.04369f
C1823 TERM_ENABLE FS_PB_CONTROL_S 0.03597f
C1824 FS_LOW_P HS_N_4 0.08963f
C1825 HS_N_6 HS_N 7.97734f
C1826 TERM_ENABLE HS_P_0 0.06288f
C1827 LS_SLOW_B TERM_GATE_P 0.11803f
C1828 PULLUP_N_BLEED_0 TERM_P_R 0.01729f
C1829 TERM_TRIM2 PULLUP_N_BLEED_1 0.04294f
C1830 HS_P_4 HS_P_9 0.03515f
C1831 HS_N_2 HS_N_1 0.11091f
C1832 TERM_TRIM2 FS_P_OUT 0.29481f
C1833 HS_N_9 TERM_GATE_N_BLEED_1 0.06246f
C1834 HS_N_8 HS_N_3 0
C1835 FS_N_WELL TERM_P_R 1.7135f
C1836 HS_N_1 PULLUP_P_BLEED_0 0.03931f
C1837 FS_PB_BLEED_1 VCM_LOW_OK 0.93092f
C1838 FS_PB_BLEED_1 HS_P 0.00212f
C1839 HS_P TERM_OR_N_NS 0.03228f
C1840 VCM_LOW_OK TERM_OR_N_NS 0.88468f
C1841 TERM_OR_N_S TERM_TRIM0 0.05758f
C1842 PULLUP_N_BLEED_5 PULLUP_N_BLEED_4 0.06025f
C1843 HS_N_4 DIV_ENABLE 0.08392f
C1844 VCM_LOW_OK TERM_OR_N_B 5.10172f
C1845 HS_P TERM_OR_N_B 0.04865f
C1846 TERM_GATE_N DIV_N 0.10329f
C1847 LS_SLOW TRIM_N_0_R 0.11893f
C1848 TRIM_N_1_R PAD_P 0.03808f
C1849 HS_P_0 HS_P_8 0.03089f
C1850 TERM_P_R TERM_TRIM0 0.19417p
C1851 FS_PB_BLEED_6 FS_HIGH_P 0.03716f
C1852 HS_P_2 HS_P_10 0.0381f
C1853 HS_N_6 PULLUP_P 0.04377f
C1854 m2_42279_124800# a_41005_134065# 0
C1855 TERM_OR_P_S HS_P_7 0.02404f
C1856 HS_N_5 HS_N_12 0
C1857 FS_PB_BLEED_5 BYPASS_ENABLE 0.00766f
C1858 HS_P_12 FS_P_WELL 0.00909f
C1859 PULLDOWN_N_R HS_P_10 0.02404f
C1860 TERM_GATE_P_BLEED_0 HS_N_6 0.04809f
C1861 HS_N_5 HS_P_9 0.02404f
C1862 TERM_GATE_N HS_N_1 0.14905f
C1863 HS_N_4 TRIM_P_0_R 0.04808f
C1864 HS_P_12 HS_P_13 60.3748f
C1865 HS_N_0 TERM_TRIM1 0.07072f
C1866 HS_P HS_N_2 0.85293f
C1867 VCM_LOW_OK HS_N_2 0.08343f
C1868 TERM_ENABLE TRIM_P_2_R 0.04889f
C1869 BYPASS_ENABLE PULLUP_N_WELL 0.00846f
C1870 HS_P_2 HS_N_9 0.05493f
C1871 TERM_LSA_GATE_N TRIM_N_0_R 0.09989f
C1872 PULLUP_P_OUT TRIM_N_0_R 0.02996f
C1873 HS_P_10 PAD_N 0.45323f
C1874 VCM_LOW_OK PULLUP_P_BLEED_0 1.57385f
C1875 HS_N_8 HS_N_12 0
C1876 HS_P PULLUP_P_BLEED_0 0.03931f
C1877 DIV_P FS_P_OUT 0.0764f
C1878 LS_SLOW HS_N_10 0.02431f
C1879 HS_N_8 HS_P_9 0.03052f
C1880 TERM_P_R TERM_LSA_GATE_P 10.2249f
C1881 LS_SLOW FS_N_GATE 0.51054f
C1882 LS_SLOW FS_NB_BLEED_2 0.00564f
C1883 HS_N_9 PULLDOWN_N_R 0.02404f
C1884 TERM_P_R TERM_GATE_P_BLEED_2 0
C1885 FS_P_GATE TERM_TRIM0 0.2363f
C1886 HS_N_9 PAD_N 1.12766f
C1887 LS_SLOW HS_N_11 0.02427f
C1888 HS_P_0 HS_N_6 0.03737f
C1889 PULLDOWN_P PULLUP_N_BLEED_5 0.00345f
C1890 HS_P_12 HS_PBIAS 4.46186f
C1891 PULLUP_P_OUT HS_N_10 0.03489f
C1892 PULLDOWN_N_R PULLUP_P_BLEED_4 0.00251f
C1893 TERM_GATE_N VCM_LOW_OK 0.01653f
C1894 TERM_GATE_N HS_P 0.15148f
C1895 HS_P_6 PAD_P 1.8942f
C1896 TERM_ENABLE TERM_GATE_P 0.20712f
C1897 FS_LOW_P TERM_VCM 0.44809f
C1898 PULLDOWN_N VDD 0.49091f
C1899 PULLUP_P_OUT HS_N_11 0.03489f
C1900 PAD_P HS_N_3 0.12845f
C1901 HS_P_1 TERM_ENABLE 0.06365f
C1902 DIV_N FS_HIGH_P 12.6299f
C1903 PULLUP_P_BLEED_2 HS_N_1 0.04023f
C1904 HS_P_12 HS_P_11 61.018f
C1905 TERM_VCM DIV_ENABLE 0.56177f
C1906 FS_HIGH_P FS_NB_GATE 0.05876f
C1907 FS_NB_BLEED_5 TERM_TRIM1 0.1244f
C1908 FS_HIGH_P HS_N_1 0.08834f
C1909 HS_P_8 TERM_GATE_P 0.15307f
C1910 TRIM_N_0_R HS_N_7 0.03489f
C1911 PULLUP_N_OUT FS_NB_CONTROL_S 0
C1912 FS_LOW_P TRIM_N_2_R 0.02404f
C1913 TERM_OR_N_B VDD 8.33603f
C1914 TERM_VCM TRIM_P_0_R 0.61812f
C1915 TERM_P_R TERM_OR_P_B 0.18067f
C1916 PAD_P HS_N_12 2.22281f
C1917 FS_PB_BLEED_6 HS_N_0 0
C1918 PULLUP_P_BLEED_2 HS_P 0.11051f
C1919 PAD_P HS_P_9 1.39785f
C1920 TRIM_N_1_R TERM_OR_N_B 0.0349f
C1921 DIV_ENABLE TRIM_N_2_R 0.08449f
C1922 TERM_P_R FS_N_BLEED_4 0.01857f
C1923 HS_N_10 HS_N_7 0.03027f
C1924 TERM_GATE_N_BLEED_1 TERM_GATE_N_BLEED_0 0.06543f
C1925 HS_P FS_HIGH_P 0.08792f
C1926 VCM_LOW_OK FS_HIGH_P 0.11493f
C1927 PULLUP_N_OUT FS_NB_BLEED_6 0.06386f
C1928 TERM_OR_P_S TERM_OR_P_NS 0.00306f
C1929 HS_N_2 VDD 4.67603f
C1930 PULLUP_P_GATE HS_PBIAS 0.15859f
C1931 FS_PB_BLEED_5 TRIM_N_0_R 0.04294f
C1932 HS_N_6 TERM_GATE_P 0.10654f
C1933 VDD PULLUP_P_BLEED_0 0.55291f
C1934 HS_P_4 HS_N_5 0.13307f
C1935 FS_PB_CONTROL_LS FS_P_WELL 0.00355f
C1936 HS_P_1 HS_N_6 0.06578f
C1937 HS_N_11 HS_N_7 0.02985f
C1938 FS_PB_GATE TERM_N_R 0.43247f
C1939 TRIM_P_0_R TRIM_N_2_R 25.5156f
C1940 TRIM_N_1_R HS_N_2 0.04858f
C1941 HS_P_12 FS_N_OUT 0.06167f
C1942 TERM_OR_N_S TERM_TRIM2 0.03589f
C1943 FS_NB_CONTROL_S FS_HIGH_N 0.40945f
C1944 HS_P_10 TERM_GATE_P_BLEED_1 0.04673f
C1945 TRIM_N_1_R PULLUP_P_BLEED_0 0.03472f
C1946 m2_42279_124800# a_41005_132945# 0
C1947 HS_P_4 HS_N_8 0.02404f
C1948 HS_P_12 PULLDOWN_P_R 0.0676f
C1949 FS_LOW_P HS_N 0.1027f
C1950 TERM_OR_P_S TERM_OR_P_B 1.93563f
C1951 LS_SLOW FS_N_BLEED_5 1.58564f
C1952 PULLDOWN_P TERM_TRIM1 0.03698f
C1953 TERM_TRIM2 TERM_P_R 0.07933f
C1954 FS_N_GATE FS_N_BLEED_1 0.14522f
C1955 HS_P_12 LS_SLOW_B 0
C1956 FS_PB_BLEED_5 HS_N_10 0.03931f
C1957 FS_LOW_N TERM_OR_N_NS 0.39034f
C1958 BYPASS_ENABLE PAD_N 11.6568f
C1959 PULLUP_N_OUT TERM_N_R 0.25001f
C1960 TERM_GATE_N VDD 2.91115f
C1961 HS_N_9 TERM_GATE_P_BLEED_1 0.00148f
C1962 FS_NB_BLEED_3 FS_N_WELL 0
C1963 TERM_OR_N_B FS_LOW_N 4.57033f
C1964 HS_P_7 TERM_TRIM0 0.0525f
C1965 FS_P_WELL TERM_TRIM1 0.96322f
C1966 HS_N DIV_ENABLE 0.11501f
C1967 TERM_TRIM1 HS_P_13 0.06879f
C1968 FS_NB_BLEED_6 FS_HIGH_N 0.1661f
C1969 PULLUP_N_WELL FS_NB_BLEED_2 0
C1970 FS_PB_BLEED_5 HS_N_11 0.03931f
C1971 HS_N_3 TERM_OR_N_NS 0.00153f
C1972 TERM_GATE_N TRIM_N_1_R 0.03312f
C1973 DIV_N HS_N_0 0.05004f
C1974 PULLUP_N_BLEED_0 TERM_TRIM0 0.02371f
C1975 TERM_OR_N_B HS_N_3 0.04808f
C1976 HS_N_8 HS_N_5 0.04894f
C1977 FS_N_WELL TERM_TRIM0 1.61787f
C1978 FS_N_BLEED_6 FS_HIGH_N 0.32875f
C1979 FS_PB_BLEED_4 VDD 0.79321f
C1980 HS_N_0 RX_N 0.00305f
C1981 FS_LOW_N HS_N_2 0.12679f
C1982 HS_N TRIM_P_0_R 0.10264f
C1983 HS_N_0 HS_N_1 0.15663p
C1984 FS_P_GATE TERM_TRIM2 0.21187f
C1985 HS_P_6 HS_N_2 0.03425f
C1986 HS_P_7 TERM_LSA_GATE_P 0.05893f
C1987 TERM_TRIM0 DIV_LOW_N 0
C1988 DIV_ENABLE PULLUP_P 0.05345f
C1989 TERM_TRIM1 HS_PBIAS 0.81129f
C1990 TRIM_N_1_R FS_PB_BLEED_4 0.04016f
C1991 TERM_P_R DIV_P 0.07738f
C1992 PULLUP_N PULLUP_N_BLEED_5 0.00878f
C1993 TERM_N_R FS_HIGH_N 0.14554f
C1994 HS_N_2 HS_N_3 0.15499p
C1995 VCM_LOW_OK PULLUP_P_CONTROL_S 0.07756f
C1996 HS_N_3 PULLUP_P_BLEED_0 0.03931f
C1997 LS_SLOW HS_N_4 0.02404f
C1998 HS_N_4 HS_P_5 0
C1999 FS_LOW_P HS_P_0 0.09951f
C2000 PULLUP_P_GATE FS_N_OUT 0.05082f
C2001 TERM_OR_N_B HS_N_12 0.04885f
C2002 TERM_GATE_N FS_LOW_N 0.23224f
C2003 PULLDOWN_P_R PULLUP_P_GATE 0.156f
C2004 VCM_LOW_OK HS_N_0 0.08578f
C2005 TERM_N_R HS_N_13 0.05952f
C2006 FS_HIGH_P FS_NB_BLEED_0 0.01347f
C2007 FS_HIGH_P VDD 0.80229f
C2008 TRIM_P_1_R HS_P_13 0.05301f
C2009 HS_N_0 HS_P 0.16181f
C2010 HS_P_4 PAD_P 1.20025f
C2011 HS_P_11 TERM_TRIM1 0.03023f
C2012 PULLDOWN_P TERM_OR_N_PLS 0.04719f
C2013 PULLDOWN_N_R DIFF_ENABLE 0
C2014 HS_P_0 DIV_ENABLE 1.88345f
C2015 PULLUP_P_GATE LS_SLOW_B 0.20185f
C2016 PULLUP_P_OUT HS_N_4 0.03489f
C2017 TERM_GATE_N HS_N_3 0.14631f
C2018 TERM_GATE_N_BLEED_1 HS_N_10 0.04001f
C2019 TRIM_N_1_R FS_HIGH_P 0.00435f
C2020 HS_P_12 TERM_ENABLE 0.06336f
C2021 TERM_OR_P_S DIV_P 0.09093f
C2022 HS_N_2 HS_N_12 0.03554f
C2023 FS_PB_GATE HS_N_9 0.30284f
C2024 PULLUP_N_OUT HS_P_10 0.03193f
C2025 HS_N_12 PULLUP_P_BLEED_0 0.03931f
C2026 HS_P_9 HS_N_2 0.02451f
C2027 FS_PB_BLEED_6 FS_P_WELL 0.00278f
C2028 TERM_GATE_N_BLEED_1 HS_N_11 0.03985f
C2029 FS_NB_BLEED_4 TERM_TRIM1 0.01523f
C2030 HS_P_0 TRIM_P_0_R 0.06075f
C2031 FS_LOW_P TRIM_P_2_R 0.03195f
C2032 FS_P_BLEED_4 TERM_TRIM1 0.04303f
C2033 TRIM_P_1_R HS_PBIAS 0
C2034 FS_PB_BLEED_0 HS_N_9 0.06246f
C2035 PAD_P HS_N_5 0.38155f
C2036 HS_P_10 HS_P_3 0.09062f
C2037 TERM_LSA_GATE_P TERM_GATE_P_BLEED_2 0.43641f
C2038 TERM_N_R TERM_GATE_N_BLEED_2 0.00257f
C2039 PULLDOWN_N_R TRIM_N_0_R 0.04828f
C2040 HS_P_7 TERM_OR_P_B 0.08279f
C2041 HS_N_9 PULLUP_N_OUT 0.01492f
C2042 HS_P_12 HS_P_8 0.03875f
C2043 FS_P_BLEED_2 TERM_TRIM1 0.01524f
C2044 FS_N_BLEED_1 FS_N_BLEED_5 0.00257f
C2045 TRIM_N_0_R PAD_N 1.55796f
C2046 FS_PB_CONTROL_LS LS_SLOW_B 1.67287f
C2047 TRIM_P_2_R DIV_ENABLE 0.06712f
C2048 PAD_P HS_N_8 0.48147f
C2049 FS_N_CONTROL_S VDD 0.84327f
C2050 TERM_OR_N_PLS HS_PBIAS 0.02984f
C2051 TERM_GATE_N HS_N_12 0.14747f
C2052 HS_N_9 HS_P_3 0.03117f
C2053 HS_P_2 HS_N_10 0.02545f
C2054 TERM_N_R PULLUP_N_BLEED_1 0.07012f
C2055 TERM_N_R FS_P_OUT 0.28454f
C2056 FS_P_BLEED_4 FS_P_BLEED_3 0.97176f
C2057 TERM_ENABLE PULLUP_N_BLEED_5 0.01256f
C2058 PULLUP_N_OUT PULLUP_P_BLEED_4 0.04543f
C2059 TERM_TRIM1 FS_N_OUT 0.26395f
C2060 FS_HIGH_P FS_LOW_N 0.11184p
C2061 PULLUP_P_GATE PULLUP_P_WELL 43.3376f
C2062 TRIM_P_1_R HS_P_11 0.09265f
C2063 PULLUP_P_BLEED_2 HS_N_3 0.04313f
C2064 PULLDOWN_N_R HS_N_10 0.02404f
C2065 PAD_P RX_P 8.57241f
C2066 PULLDOWN_P_R TERM_TRIM1 0.03671f
C2067 FS_P_BLEED_2 FS_P_BLEED_3 0.04499f
C2068 HS_P_2 HS_N_11 0.02508f
C2069 PULLDOWN_N_R FS_N_GATE 0.46974f
C2070 PULLDOWN_N_R FS_NB_BLEED_2 0.05831f
C2071 PAD_N HS_N_10 1.38348f
C2072 FS_LOW_P TERM_GATE_P 0.08982f
C2073 TRIM_P_2_R TRIM_P_0_R 0.03665f
C2074 LS_SLOW TERM_VCM 1.3521f
C2075 TERM_VCM HS_P_5 0.1923f
C2076 HS_P PULLUP_N_BLEED_4 0.00212f
C2077 PULLDOWN_N_R HS_N_11 0.02404f
C2078 FS_HIGH_P HS_N_3 0.08792f
C2079 LS_SLOW_B TERM_TRIM1 0.08662f
C2080 DIV_N PULLDOWN_P 0.06047f
C2081 HS_P_1 FS_LOW_P 0.21433f
C2082 HS_N_4 HS_N_7 0.06976f
C2083 TERM_GATE_P TERM_OR_P_PLS 1.5343f
C2084 HS_P_12 HS_N_6 0.03089f
C2085 PULLUP_P_CONTROL_S VDD 0.41895f
C2086 PULLUP_P_BLEED_3 HS_N_5 0
C2087 PAD_N HS_N_11 1.25063f
C2088 HS_P_7 TERM_TRIM2 0.02846f
C2089 TERM_TRIM0 FS_N_BLEED_4 0.02536f
C2090 DIV_N FS_P_WELL 1.0576f
C2091 TERM_GATE_P DIV_ENABLE 0.02684f
C2092 TERM_ENABLE PULLUP_P_GATE 0.27674f
C2093 PULLDOWN_P FS_NB_GATE 1.65045f
C2094 PULLDOWN_P HS_N_1 0.06787f
C2095 TERM_VCM TERM_LSA_GATE_N 5.07269f
C2096 HS_P_1 DIV_ENABLE 0.03996f
C2097 PULLUP_P_OUT TERM_VCM 0.6863f
C2098 PULLUP_N_BLEED_0 TERM_TRIM2 0.06124f
C2099 PULLUP_P_BLEED_3 HS_N_8 0.00108f
C2100 TERM_LSA_GATE_P TERM_OR_P_B 7.70553f
C2101 HS_N_0 VDD 4.42559f
C2102 PULLUP_P_BLEED_2 HS_N_12 0.03973f
C2103 HS_N_9 HS_N_13 0.15155f
C2104 FS_P_WELL HS_N_1 1.1731f
C2105 LS_SLOW TRIM_N_2_R 0.14691f
C2106 FS_N_WELL TERM_TRIM2 1.39861f
C2107 TRIM_N_2_R HS_P_5 0
C2108 HS_N_1 HS_P_13 0.09588f
C2109 FS_PB_BLEED_5 HS_N_4 0.03931f
C2110 TERM_GATE_P TRIM_P_0_R 0.03154f
C2111 HS_N_0 TRIM_N_1_R 0.0598f
C2112 FS_HIGH_P HS_N_12 0.08813f
C2113 TERM_P_R PULLUP_N_BLEED_6 0.04606f
C2114 HS_P_1 TRIM_P_0_R 0.04808f
C2115 PULLUP_N_GATE PULLDOWN_N 0.00133f
C2116 TERM_TRIM2 DIV_LOW_N 0.00778f
C2117 TERM_TRIM2 TERM_TRIM0 0.11105f
C2118 DIV_N HS_PBIAS 0.14808f
C2119 PULLDOWN_P_R TRIM_P_1_R 0.08733f
C2120 TERM_LSA_GATE_N TRIM_N_2_R 0.09433f
C2121 PULLUP_P_OUT TRIM_N_2_R 0.06417f
C2122 FS_PB_CONTROL_LS TERM_ENABLE 0.13374f
C2123 HS_P_7 DIV_P 0.04218f
C2124 HS_P PULLDOWN_P 0.02404f
C2125 VCM_LOW_OK PULLDOWN_P 0.90082f
C2126 PULLUP_P_WELL TERM_TRIM1 0.23996f
C2127 LS_SLOW_B TRIM_P_1_R 0.0704f
C2128 FS_NB_GATE HS_PBIAS 0.50386f
C2129 HS_N_5 TERM_OR_N_NS 0.00258f
C2130 FS_PB_BLEED_1 HS_N_5 0
C2131 HS_PBIAS HS_N_1 9.5956f
C2132 HS_P FS_P_WELL 1.2723f
C2133 VCM_LOW_OK FS_P_WELL 4.30365f
C2134 PULLUP_N_BLEED_3 HS_N 0.24283f
C2135 HS_N_9 TERM_GATE_N_BLEED_2 0.00148f
C2136 TERM_OR_N_B HS_N_5 0.04808f
C2137 HS_P HS_P_13 0.68614f
C2138 VCM_LOW_OK HS_P_13 0.13109f
C2139 FS_P_BLEED_6 HS_N_1 0.03845f
C2140 FS_PB_BLEED_6 FS_N_OUT 0.35543f
C2141 FS_N_GATE FS_N_BLEED_0 0.00131f
C2142 TERM_OR_P_NS TERM_OR_P_B 0.61458f
C2143 FS_PB_BLEED_1 HS_N_8 0.00108f
C2144 HS_N_8 TERM_OR_N_NS 0.00704f
C2145 LS_SLOW HS_N 0.04797f
C2146 HS_N HS_P_5 0.35106f
C2147 HS_N_6 PULLUP_P_GATE 0.05157f
C2148 HS_N_8 TERM_OR_N_B 0.04841f
C2149 TERM_ENABLE TERM_TRIM1 0.09825f
C2150 HS_N_9 FS_P_OUT 0.71652f
C2151 HS_N_0 FS_LOW_N 0.08516f
C2152 TERM_VCM HS_N_7 0.31065f
C2153 DIV_P TERM_TRIM0 0.01706f
C2154 FS_NB_BLEED_5 VDD 0.79321f
C2155 FS_PB_BLEED_2 FS_PB_BLEED_1 0.18267f
C2156 HS_P_6 HS_N_0 0.03425f
C2157 HS_N_5 HS_N_2 0.00106f
C2158 HS_P_11 HS_N_1 0.02846f
C2159 HS_N_5 PULLUP_P_BLEED_0 0.03931f
C2160 HS_P HS_PBIAS 0.19484p
C2161 VCM_LOW_OK HS_PBIAS 0.49848f
C2162 PULLUP_P_OUT HS_N 0.04828f
C2163 HS_N_0 HS_N_3 0.07842f
C2164 PULLDOWN_N_R FS_N_BLEED_5 0.05281f
C2165 ESD_RAIL a_41005_131825# 0.53823f
C2166 HS_N_8 HS_N_2 0
C2167 DIV_N FS_P_BLEED_4 0.10151f
C2168 HS_P FS_P_BLEED_6 0.1064f
C2169 HS_P_8 TERM_TRIM1 0.02404f
C2170 HS_N_8 PULLUP_P_BLEED_0 0.03931f
C2171 FS_NB_BLEED_6 TERM_P_R 0.05771f
C2172 LS_SLOW PULLUP_P 1.44288f
C2173 m2_42279_124800# a_41005_131545# 0.05457f
C2174 FS_HIGH_P FS_P_CONTROL_S 0.61127f
C2175 HS_N_4 TERM_GATE_N_BLEED_1 0.04421f
C2176 DIV_P TERM_LSA_GATE_P 0.17111f
C2177 TERM_GATE_P_BLEED_0 HS_P_5 0
C2178 BYPASS_ENABLE FS_HIGH_N 0
C2179 FS_PB_BLEED_5 TERM_VCM 0.04294f
C2180 FS_P_BLEED_4 HS_N_1 0.03931f
C2181 TERM_GATE_N HS_N_5 0.14749f
C2182 VCM_LOW_OK HS_P_11 0.14693f
C2183 TERM_VCM PULLUP_N_WELL 0.18462f
C2184 HS_P HS_P_11 5.65023f
C2185 PULLUP_P_OUT PULLUP_P 0.07553f
C2186 DIV_N FS_N_OUT 0.08655f
C2187 TERM_OR_N_S TERM_N_R 0.28624f
C2188 DIV_N PULLDOWN_P_R 0
C2189 TERM_GATE_N HS_N_8 0.14897f
C2190 LS_SLOW FS_PB_CONTROL_S 0.05497f
C2191 FS_PB_BLEED_6 PULLUP_P_WELL 0
C2192 TERM_ENABLE TRIM_P_1_R 0.04922f
C2193 HS_N_0 HS_N_12 0.03942f
C2194 LS_SLOW HS_P_0 0.06301f
C2195 HS_P_0 HS_P_5 0.03089f
C2196 TERM_N_R TERM_P_R 35.8456f
C2197 HS_N_6 TERM_TRIM1 0.02478f
C2198 RX_N FS_N_OUT 0.01566f
C2199 ESD_RAIL a_41005_134065# 0.57348f
C2200 HS_N_0 HS_P_9 0.02689f
C2201 FS_NB_GATE FS_N_OUT 27.1508f
C2202 TERM_P_R FS_PB_BLEED_3 0.04893f
C2203 FS_PB_BLEED_5 TRIM_N_2_R 0.05336f
C2204 PULLDOWN_P_R HS_N_1 0.05934f
C2205 HS_P_2 HS_N_4 0.0278f
C2206 PULLDOWN_P VDD 1.31143f
C2207 VCM_LOW_OK FS_P_BLEED_4 0.04585f
C2208 TERM_TRIM2 FS_N_BLEED_4 0.06152f
C2209 HS_P FS_P_BLEED_4 0.03931f
C2210 PULLUP_P_OUT FS_PB_CONTROL_S 0.06889f
C2211 FS_NB_GATE LS_SLOW_B 0.52683f
C2212 LS_SLOW_B HS_N_1 0.05016f
C2213 FS_P_WELL VDD 0.10924p
C2214 PULLDOWN_N_R HS_N_4 0.02404f
C2215 FS_PB_GATE TRIM_N_0_R 0.17839f
C2216 PULLUP_P_OUT HS_P_0 0.05519f
C2217 HS_P_8 TRIM_P_1_R 0.04811f
C2218 HS_N HS_N_7 0.69419f
C2219 TRIM_N_1_R PULLDOWN_P 0.03698f
C2220 HS_P_12 FS_LOW_P 0.08684f
C2221 VDD HS_P_13 6.5154f
C2222 HS_N_4 PAD_N 1.32462f
C2223 FS_P_BLEED_0 VCM_LOW_OK 0.13486f
C2224 FS_P_BLEED_0 HS_P 0.00154f
C2225 PULLUP_P_BLEED_2 HS_N_5 0.0458f
C2226 TRIM_N_1_R FS_P_WELL 0.83855f
C2227 TERM_N_R FS_P_GATE 0.29345f
C2228 TRIM_N_1_R HS_P_13 0.03147f
C2229 FS_N_BLEED_5 FS_N_BLEED_0 0.00257f
C2230 TERM_OR_P_S TERM_N_R 0.09731f
C2231 VCM_LOW_OK FS_N_OUT 0.1125f
C2232 HS_P FS_N_OUT 1.05504f
C2233 PULLUP_N_OUT TRIM_N_0_R 0.05244f
C2234 HS_P_12 DIV_ENABLE 0.03996f
C2235 LS_SLOW TRIM_P_2_R 0.25871f
C2236 PAD_P HS_N_2 1.29151f
C2237 HS_P PULLUP_N_CONTROL_S 0.03228f
C2238 DIV_P TERM_OR_P_B 0.00776f
C2239 VCM_LOW_OK PULLDOWN_P_R 38.5157f
C2240 PULLUP_P_BLEED_2 HS_N_8 0.05643f
C2241 FS_HIGH_P HS_N_5 0.08792f
C2242 HS_P PULLDOWN_P_R 0.06537f
C2243 BYPASS_ENABLE PULLUP_N_BLEED_1 0.00766f
C2244 FS_PB_GATE HS_N_10 0.29436f
C2245 FS_HIGH_P PULLUP_N_GATE 0.00719f
C2246 FS_HIGH_N DIFF_ENABLE 0.25832f
C2247 FS_PB_BLEED_5 HS_N 0.05271f
C2248 PULLUP_P HS_N_7 0.05062f
C2249 HS_PBIAS VDD 81.2219f
C2250 HS_P PULLUP_N 0.0019f
C2251 VCM_LOW_OK LS_SLOW_B 0.05399f
C2252 FS_HIGH_P HS_N_8 0.08792f
C2253 DIV_N PULLUP_P_WELL 0.08038f
C2254 FS_PB_GATE HS_N_11 0.29413f
C2255 HS_N_6 TRIM_P_1_R 0
C2256 TERM_GATE_P_BLEED_0 HS_N_7 0.05151f
C2257 FS_PB_BLEED_0 HS_N_10 0.04001f
C2258 PULLUP_N_WELL HS_N 0.7198f
C2259 HS_P_12 TRIM_P_0_R 0.04808f
C2260 PULLUP_P_OUT TRIM_P_2_R 0.08624f
C2261 TRIM_N_1_R HS_PBIAS 0.17751f
C2262 PULLDOWN_P FS_LOW_N 0.18498f
C2263 PULLUP_N_OUT FS_N_GATE 0.47936f
C2264 PULLDOWN_P FS_NB_CONTROL_LS 0.02611f
C2265 PULLUP_N_OUT FS_NB_BLEED_2 0
C2266 PULLUP_P_WELL HS_N_1 0.15008f
C2267 FS_PB_BLEED_0 HS_N_11 0.03985f
C2268 a_41005_133505# a_41005_134065# 0.0346f
C2269 LS_SLOW TERM_GATE_P 5.35934f
C2270 HS_P_3 HS_N_10 0.02545f
C2271 TERM_GATE_P HS_P_5 0.15464f
C2272 HS_P_11 VDD 5.78711f
C2273 PULLUP_N_BLEED_6 TERM_TRIM0 0.01882f
C2274 FS_NB_BLEED_1 HS_PBIAS 0.09581f
C2275 FS_N_BLEED_1 PULLUP_P 0
C2276 PULLDOWN_P HS_N_3 0.02404f
C2277 HS_P_1 LS_SLOW 0.06718f
C2278 HS_P_10 TERM_P_R 0.14875f
C2279 HS_P_1 HS_P_5 0
C2280 HS_P_6 HS_P_13 0.11948f
C2281 HS_P_0 HS_N_7 0
C2282 TERM_TRIM2 DIV_P 0.01603f
C2283 a_43813_117064# a_44789_117064# 3.03168f
C2284 PULLUP_P_BLEED_3 PULLUP_P_BLEED_0 0.00929f
C2285 HS_N_11 HS_P_3 0.02508f
C2286 PULLUP_N_WELL PULLUP_P 0.44426f
C2287 HS_P_2 TERM_VCM 0.1923f
C2288 FS_P_WELL HS_N_3 0.9576f
C2289 TRIM_N_1_R HS_P_11 0.02404f
C2290 FS_LOW_P PULLUP_P_GATE 0.06878f
C2291 TERM_ENABLE FS_NB_GATE 0.67421f
C2292 TERM_ENABLE HS_N_1 0.08158f
C2293 PULLUP_P_OUT TERM_GATE_P 0.30087f
C2294 HS_N_9 TERM_P_R 0.09409f
C2295 PULLDOWN_N_R TERM_VCM 0.6099f
C2296 TRIM_N_0_R HS_N_13 0.03489f
C2297 DIV_N HS_P_8 0.01203f
C2298 HS_P PULLUP_P_WELL 0.19828f
C2299 VCM_LOW_OK PULLUP_P_WELL 0.58742f
C2300 FS_N_GATE FS_HIGH_N 2.75071f
C2301 FS_P_BLEED_4 VDD 0.54381f
C2302 FS_LOW_N HS_PBIAS 0.39871f
C2303 FS_N_WELL FS_NB_CONTROL_S 0.0716f
C2304 PULLUP_P_GATE DIV_ENABLE 0
C2305 HS_P_6 HS_PBIAS 5.95494f
C2306 TERM_OR_N_B TERM_OR_N_NS 1.23344f
C2307 FS_N_BLEED_3 LS_SLOW_B 0.83369f
C2308 HS_P_10 FS_P_GATE 0.00226f
C2309 FS_P_BLEED_2 VDD 0.00239f
C2310 PULLDOWN_P HS_N_12 0.07315f
C2311 HS_P_8 HS_N_1 0.03489f
C2312 TERM_OR_P_S HS_P_10 0.02404f
C2313 TRIM_N_1_R FS_P_BLEED_4 0.04163f
C2314 DIFF_ENABLE PULLUP_N_BLEED_1 0.00113f
C2315 HS_P_2 TRIM_N_2_R 0
C2316 HS_N_3 HS_PBIAS 1.39899f
C2317 ESD_RAIL a_41005_132945# 0.53823f
C2318 FS_P_BLEED_0 VDD 0.03624f
C2319 HS_N_13 HS_N_10 0.03794f
C2320 FS_NB_BLEED_3 FS_NB_BLEED_6 0.1071f
C2321 FS_P_WELL HS_N_12 1.02236f
C2322 FS_N_GATE HS_N_13 0.01445f
C2323 HS_N TERM_GATE_N_BLEED_1 0.22944f
C2324 VCM_LOW_OK TERM_ENABLE 0.20379f
C2325 TRIM_N_1_R FS_P_BLEED_2 0
C2326 FS_P_BLEED_6 HS_N_3 0.04123f
C2327 FS_N_WELL FS_NB_BLEED_6 0.00637f
C2328 PULLDOWN_N_R TRIM_N_2_R 0.04614f
C2329 HS_P TERM_ENABLE 0.02591f
C2330 HS_N_9 FS_P_GATE 0.24231f
C2331 PULLUP_N_CONTROL_S VDD 0.34188f
C2332 VDD FS_N_OUT 10.6123f
C2333 HS_P_9 HS_P_13 0.09043f
C2334 TERM_OR_P_S HS_N_9 0.02404f
C2335 PULLDOWN_P_R VDD 1.29916f
C2336 HS_N_0 HS_N_5 0.03911f
C2337 PAD_N TRIM_N_2_R 0.32595f
C2338 HS_N_11 HS_N_13 0.10514f
C2339 HS_P_6 HS_P_11 0.03877f
C2340 TERM_OR_N_B HS_N_2 0.04855f
C2341 DIV_N HS_N_6 0.04218f
C2342 FS_NB_BLEED_6 TERM_TRIM0 0.04477f
C2343 FS_N_WELL FS_N_BLEED_6 0.00372f
C2344 HS_P_7 TERM_N_R 0.05016f
C2345 TRIM_N_1_R FS_N_OUT 0.00144f
C2346 PULLUP_N VDD 0.00404f
C2347 LS_SLOW_B VDD 6.54925f
C2348 TRIM_N_1_R PULLDOWN_P_R 0.05062f
C2349 HS_N_0 HS_N_8 0.03911f
C2350 FS_P_OUT TRIM_N_0_R 0.16198f
C2351 VCM_LOW_OK HS_P_8 0.08296f
C2352 HS_P HS_P_8 3.04259f
C2353 HS_N_6 HS_N_1 0.04294f
C2354 HS_N_12 HS_PBIAS 2.63945f
C2355 FS_P_BLEED_5 HS_N_10 0
C2356 TERM_GATE_P HS_N_7 0.107f
C2357 TRIM_N_1_R LS_SLOW_B 0.07315f
C2358 HS_P_2 HS_N 0.53581f
C2359 FS_N_WELL TERM_N_R 1.67858f
C2360 PULLUP_P_BLEED_3 PULLUP_P_BLEED_2 0.034f
C2361 PULLUP_P_BLEED_1 HS_N_10 0
C2362 HS_N_2 PULLUP_P_BLEED_0 0.03931f
C2363 HS_P_9 HS_PBIAS 2.18028f
C2364 HS_P_1 HS_N_7 0.03503f
C2365 FS_P_BLEED_6 HS_N_12 0.03795f
C2366 TERM_GATE_N TERM_OR_N_B 5.55603f
C2367 PULLUP_N_OUT FS_N_BLEED_5 0.06391f
C2368 FS_P_BLEED_5 HS_N_11 0
C2369 PULLDOWN_N_R HS_N 0.03055f
C2370 DIV_ENABLE TERM_TRIM1 0.21571f
C2371 FS_P_OUT HS_N_10 0.72352f
C2372 TERM_N_R TERM_TRIM0 0.21937f
C2373 PULLUP_P_BLEED_1 HS_N_11 0
C2374 FS_P_BLEED_4 HS_N_3 0.03931f
C2375 PAD_N HS_N 35.6829f
C2376 TERM_TRIM0 FS_PB_BLEED_3 0.02029f
C2377 HS_P_11 HS_N_12 0.11035f
C2378 FS_P_OUT HS_N_11 0.7213f
C2379 FS_N_BLEED_3 TERM_ENABLE 0.16736f
C2380 FS_LOW_N FS_N_OUT 0.27321f
C2381 HS_P HS_N_6 1.04395f
C2382 VCM_LOW_OK HS_N_6 0.08296f
C2383 TERM_GATE_N HS_N_2 0.14679f
C2384 HS_P_9 HS_P_11 0.02868f
C2385 PULLDOWN_P_R FS_LOW_N 0.10673f
C2386 HS_P_6 FS_N_OUT 0.06167f
C2387 TRIM_P_0_R TERM_TRIM1 0.00154f
C2388 a_41005_132945# a_41005_133505# 0.0346f
C2389 HS_P_6 PULLDOWN_P_R 0.0676f
C2390 PULLUP_P_WELL VDD 22.4537f
C2391 HS_P_2 TERM_GATE_P_BLEED_0 0
C2392 FS_LOW_N LS_SLOW_B 0.05016f
C2393 HS_N_3 FS_N_OUT 0.06167f
C2394 TERM_N_R TERM_LSA_GATE_P 0.2136f
C2395 PULLDOWN_N_R PULLUP_P 0.05799f
C2396 FS_NB_CONTROL_LS LS_SLOW_B 1.08701f
C2397 HS_P_6 LS_SLOW_B 0.04331f
C2398 PULLDOWN_P_R HS_N_3 0.05893f
C2399 FS_PB_GATE HS_N_4 0.29305f
C2400 FS_HIGH_N FS_N_BLEED_5 0.22024f
C2401 TRIM_N_1_R PULLUP_P_WELL 0.22799f
C2402 FS_LOW_P TRIM_P_1_R 0.02404f
C2403 PULLUP_N_BLEED_4 PULLUP_N_GATE 0.81353f
C2404 FS_P_BLEED_4 HS_N_12 0.03931f
C2405 TERM_TRIM2 PULLUP_N_BLEED_6 0.00333f
C2406 FS_PB_BLEED_0 HS_N_4 0.04421f
C2407 TERM_ENABLE VDD 9.0829f
C2408 HS_N_0 PAD_P 0.18047f
C2409 HS_P_2 HS_P_0 0.03103f
C2410 HS_P_7 HS_P_10 0.0513f
C2411 TRIM_P_1_R DIV_ENABLE 0.06374f
C2412 PULLUP_N_OUT HS_N_4 0.00298f
C2413 FS_HIGH_P TERM_OR_N_B 0.01431f
C2414 DIV_LOW_P TERM_P_R 0.0421f
C2415 PULLDOWN_N_R FS_PB_CONTROL_S 0.00267f
C2416 FS_PB_BLEED_6 FS_LOW_P 0.1364f
C2417 PULLDOWN_N_R HS_P_0 0.0785f
C2418 TRIM_N_1_R TERM_ENABLE 0.05353f
C2419 HS_P_12 LS_SLOW 0.07568f
C2420 HS_P_12 HS_P_5 0
C2421 HS_P_4 HS_P_13 0.14463f
C2422 TERM_OR_P_S BYPASS_ENABLE 0.00444f
C2423 HS_N_12 FS_N_OUT 0.00708f
C2424 PULLUP_P_BLEED_2 HS_N_2 0.03931f
C2425 HS_N_4 HS_P_3 0.00972f
C2426 HS_P_7 HS_N_9 0.03983f
C2427 PULLUP_P_BLEED_2 PULLUP_P_BLEED_0 0.00131f
C2428 HS_P_0 PAD_N 0.41792f
C2429 PULLDOWN_P_R HS_N_12 0.05913f
C2430 HS_P_8 VDD 5.01934f
C2431 HS_N FS_N_BLEED_0 0.24141f
C2432 TRIM_P_1_R TRIM_P_0_R 26.1797f
C2433 PULLDOWN_P_R HS_P_9 0.02418f
C2434 FS_PB_BLEED_6 DIV_ENABLE 0
C2435 FS_HIGH_P HS_N_2 0.09916f
C2436 PULLDOWN_P HS_N_5 0.07706f
C2437 FS_HIGH_P PULLUP_P_BLEED_0 0.166f
C2438 HS_P_10 TERM_TRIM0 0.02404f
C2439 PULLUP_P_OUT HS_P_12 0.06674f
C2440 TRIM_N_1_R HS_P_8 0.02404f
C2441 PULLDOWN_P FS_N_BLEED_2 0.00345f
C2442 PULLDOWN_P PULLUP_N_GATE 0.20174f
C2443 FS_P_WELL HS_N_5 0.95374f
C2444 HS_P_4 HS_PBIAS 1.75997f
C2445 HS_N_3 PULLUP_P_WELL 0.11601f
C2446 PULLDOWN_P HS_N_8 0.06787f
C2447 HS_N_5 HS_P_13 0.03089f
C2448 TERM_N_R TERM_OR_P_B 0.15411f
C2449 HS_N_9 TERM_TRIM0 0.04808f
C2450 PULLDOWN_N_R TRIM_P_2_R 0
C2451 LS_SLOW PULLUP_N_BLEED_5 0.06975f
C2452 TERM_P_R DIFF_ENABLE 3.04367f
C2453 FS_P_WELL HS_N_8 1.0107f
C2454 TERM_ENABLE FS_LOW_N 0.1276f
C2455 FS_NB_BLEED_6 TERM_TRIM2 0.04294f
C2456 TERM_ENABLE FS_NB_CONTROL_LS 0.03765f
C2457 HS_N_8 HS_P_13 0.02424f
C2458 HS_P_6 TERM_ENABLE 0.07634f
C2459 TERM_GATE_N FS_HIGH_P 0.17592f
C2460 HS_N_6 VDD 6.34052f
C2461 HS_P_10 TERM_LSA_GATE_P 0.05893f
C2462 FS_PB_GATE TERM_VCM 0.22086f
C2463 HS_N_4 HS_N_13 0.14463f
C2464 HS_P_4 HS_P_11 0
C2465 FS_PB_BLEED_2 FS_P_WELL 0.00387f
C2466 TERM_OR_N_S TRIM_N_0_R 0.03519f
C2467 TERM_ENABLE HS_N_3 0.02404f
C2468 DIV_N FS_LOW_P 6.01703f
C2469 TRIM_N_1_R HS_N_6 0.04808f
C2470 HS_N_5 HS_PBIAS 2.62037f
C2471 HS_N_9 TERM_LSA_GATE_P 0.05893f
C2472 HS_P_2 TERM_GATE_P 0.15676f
C2473 FS_P_BLEED_6 HS_N_5 0.04381f
C2474 PULLUP_P_WELL HS_N_12 0.12583f
C2475 HS_P_6 HS_P_8 0.03192f
C2476 TERM_P_R TRIM_N_0_R 0.99629f
C2477 LS_SLOW PULLUP_P_GATE 1.51417f
C2478 PULLUP_N_GATE HS_PBIAS 0.16144f
C2479 FS_LOW_P FS_NB_GATE 0.28497f
C2480 HS_P_2 HS_P_1 0.00846f
C2481 PULLUP_N_OUT TERM_VCM 0.87598f
C2482 FS_LOW_P HS_N_1 0.08963f
C2483 HS_N_8 HS_PBIAS 9.64211f
C2484 DIV_N DIV_ENABLE 41.4227f
C2485 PULLDOWN_N_R TERM_GATE_P 0.26094f
C2486 TERM_N_R TERM_TRIM2 0.28786f
C2487 HS_P_8 HS_N_3 0.03489f
C2488 HS_N_8 FS_P_BLEED_6 0.05411f
C2489 HS_P_1 PULLDOWN_N_R 0.02404f
C2490 FS_PB_GATE TRIM_N_2_R 0.22765f
C2491 TERM_VCM HS_P_3 0.1923f
C2492 TERM_TRIM2 FS_PB_BLEED_3 0.00333f
C2493 FS_NB_GATE DIV_ENABLE 0.00269f
C2494 RX_N DIV_ENABLE 0.7437f
C2495 TERM_GATE_P_BLEED_0 TERM_GATE_P_BLEED_1 0.034f
C2496 HS_N_0 TERM_OR_N_B 0.0509f
C2497 HS_P_1 PAD_N 0.59554f
C2498 HS_N_5 HS_P_11 0.03089f
C2499 DIV_ENABLE HS_N_1 0.09165f
C2500 PULLUP_P_OUT PULLUP_P_GATE 11.1128f
C2501 TERM_P_R HS_N_10 0.09523f
C2502 PULLUP_P_CONTROL_S PULLUP_P_BLEED_0 0
C2503 TERM_ENABLE HS_N_12 0.02421f
C2504 DIV_N TRIM_P_0_R 0
C2505 TERM_P_R FS_N_GATE 0.3538f
C2506 TERM_ENABLE HS_P_9 0.03494f
C2507 FS_P_GATE TRIM_N_0_R 0.13592f
C2508 HS_N_8 HS_P_11 0.02857f
C2509 HS_N_6 FS_LOW_N 0.08542f
C2510 HS_N_4 FS_P_OUT 0.7159f
C2511 PULLUP_N_OUT TRIM_N_2_R 0.1043f
C2512 TERM_P_R HS_N_11 0.09485f
C2513 TERM_OR_P_S TRIM_N_0_R 0.05948f
C2514 VCM_LOW_OK FS_LOW_P 0.47938f
C2515 HS_P_6 HS_N_6 0.04535f
C2516 HS_P FS_LOW_P 0.1023f
C2517 TRIM_P_0_R HS_N_1 0.05002f
C2518 HS_N_0 HS_N_2 0.03925f
C2519 TERM_VCM FS_HIGH_N 0.03743f
C2520 HS_P_10 TERM_OR_P_B 0.08226f
C2521 HS_N_0 PULLUP_P_BLEED_0 0.03931f
C2522 HS_P_0 TERM_GATE_P_BLEED_1 0.00802f
C2523 VCM_LOW_OK TERM_OR_P_PLS 0.00156f
C2524 HS_P_4 PULLDOWN_P_R 0.06095f
C2525 HS_P_3 TRIM_N_2_R 0
C2526 HS_N_5 FS_P_BLEED_4 0.03931f
C2527 HS_P_8 HS_N_12 0.03489f
C2528 HS_N_6 HS_N_3 0.00106f
C2529 PAD_P HS_P_13 1.41767f
C2530 HS_P_8 HS_P_9 44.3648f
C2531 VCM_LOW_OK DIV_ENABLE 0.05781f
C2532 PULLUP_N_BLEED_4 PULLDOWN_N 0.00763f
C2533 HS_P DIV_ENABLE 0.09755f
C2534 FS_P_GATE HS_N_10 0.23617f
C2535 FS_PB_GATE HS_N 0.39233f
C2536 FS_N_WELL BYPASS_ENABLE 0.06672f
C2537 PULLUP_P_OUT FS_PB_CONTROL_LS 0.09057f
C2538 ESD_RAIL a_53878_131545# 0.56772f
C2539 HS_N_8 FS_P_BLEED_4 0.03931f
C2540 HS_N_9 TERM_OR_P_B 0.05871f
C2541 TERM_OR_P_S HS_N_10 0.02404f
C2542 LS_SLOW TERM_TRIM1 0.09564f
C2543 FS_P_BLEED_0 HS_N_5 0
C2544 TERM_VCM HS_N_13 0.24038f
C2545 TERM_TRIM1 HS_P_5 0.02411f
C2546 ESD_RAIL a_41005_131545# 97.1325f
C2547 FS_P_GATE HS_N_11 0.23557f
C2548 FS_PB_BLEED_0 HS_N 0.22802f
C2549 TERM_GATE_N HS_N_0 0.15015f
C2550 TERM_OR_P_S HS_N_11 0.02404f
C2551 HS_P TRIM_P_0_R 0.06075f
C2552 VCM_LOW_OK TRIM_P_0_R 0.04128f
C2553 PULLDOWN_P_R HS_N_5 0.05893f
C2554 FS_P_BLEED_0 HS_N_8 0
C2555 PULLUP_N_OUT HS_N 0.10855f
C2556 TERM_P_R PULLUP_P_BLEED_5 0.04893f
C2557 PULLUP_N_CONTROL_S PULLUP_N_GATE 0.98801f
C2558 TERM_LSA_GATE_N TERM_TRIM1 0.26054f
C2559 PULLUP_P_GATE HS_N_7 0.0526f
C2560 PULLUP_P_OUT TERM_TRIM1 0.11292f
C2561 HS_N_6 HS_N_12 0
C2562 HS_N HS_P_3 0.27803f
C2563 HS_P_9 HS_N_6 0.02404f
C2564 PULLDOWN_P_R HS_N_8 0.05893f
C2565 PULLUP_N PULLUP_N_GATE 2.65665f
C2566 BYPASS_ENABLE TERM_LSA_GATE_P 0.00766f
C2567 RX_P FS_N_OUT 0.01284f
C2568 DIV_LOW_P TERM_TRIM0 0.03199f
C2569 HS_N_8 LS_SLOW_B 0.05016f
C2570 FS_PB_BLEED_2 PULLDOWN_P_R 0.00488f
C2571 HS_N_9 TERM_TRIM2 0.00365f
C2572 PULLDOWN_P PULLDOWN_N 2.82816f
C2573 PULLUP_N_OUT PULLUP_P 38.0103f
C2574 PAD_P HS_P_11 1.32891f
C2575 TERM_VCM PULLUP_N_BLEED_1 0.0562f
C2576 TERM_VCM FS_P_OUT 0.65893f
C2577 FS_PB_BLEED_5 PULLUP_P_GATE 0.02972f
C2578 FS_PB_GATE FS_PB_CONTROL_S 0.70098f
C2579 HS_N FS_HIGH_N 0.21253f
C2580 PULLUP_P_BLEED_2 HS_N_0 0.04058f
C2581 LS_SLOW TRIM_P_1_R 0.08308f
C2582 TERM_GATE_P TERM_GATE_P_BLEED_1 0.8772f
C2583 TRIM_P_1_R HS_P_5 0.0491f
C2584 TERM_GATE_P_BLEED_0 HS_P_3 0
C2585 HS_P_1 TERM_GATE_P_BLEED_1 0.06991f
C2586 PULLUP_P_BLEED_3 HS_PBIAS 0.01803f
C2587 HS_P_10 DIV_P 0.04275f
C2588 TERM_P_R FS_N_BLEED_5 0.05771f
C2589 FS_LOW_P VDD 3.48301f
C2590 FS_LOW_P FS_NB_BLEED_0 0.05872f
C2591 HS_P_4 TERM_ENABLE 0.02425f
C2592 HS_N_0 FS_HIGH_P 0.08841f
C2593 PULLDOWN_P TERM_OR_N_NS 0.03832f
C2594 LS_SLOW TERM_OR_N_PLS 2.0399f
C2595 PULLUP_N_OUT FS_PB_CONTROL_S 0.19037f
C2596 HS_N HS_N_13 0.98202f
C2597 PULLDOWN_P TERM_OR_N_B 0.10939f
C2598 HS_N_5 PULLUP_P_WELL 0.1214f
C2599 VDD TERM_OR_P_PLS 5.96804f
C2600 PULLUP_N_OUT HS_P_0 0.14852f
C2601 PULLUP_P_OUT TRIM_P_1_R 0.10601f
C2602 FS_PB_BLEED_1 FS_P_WELL 0.00522f
C2603 FS_P_OUT TRIM_N_2_R 0.15276f
C2604 HS_P_7 TRIM_N_0_R 0.02846f
C2605 TRIM_N_1_R FS_LOW_P 0.02404f
C2606 HS_N_9 DIV_P 0.04369f
C2607 DIV_ENABLE VDD 0.1351f
C2608 PULLUP_P FS_HIGH_N 0.09758f
C2609 TERM_TRIM1 HS_N_7 0.07004f
C2610 DIV_ENABLE FS_NB_BLEED_0 0
C2611 HS_N_8 PULLUP_P_WELL 0.1362f
C2612 HS_P_0 HS_P_3 0.06569f
C2613 HS_P_4 HS_P_8 0.02435f
C2614 HS_P_2 HS_P_12 0.02949f
C2615 TRIM_N_1_R DIV_ENABLE 0.08832f
C2616 PAD_P FS_N_OUT 0.24132f
C2617 PULLDOWN_P HS_N_2 0.02404f
C2618 PULLDOWN_P PULLUP_P_BLEED_0 0
C2619 TERM_ENABLE HS_N_5 0.02448f
C2620 FS_PB_BLEED_2 PULLUP_P_WELL 0
C2621 PAD_P PULLDOWN_P_R 2.98212f
C2622 PULLUP_P_OUT FS_PB_BLEED_6 0.00257f
C2623 HS_P_12 PULLDOWN_N_R 0.07466f
C2624 HS_N_13 PULLUP_P 0.04377f
C2625 TRIM_P_0_R VDD 0.26829f
C2626 FS_P_WELL HS_N_2 0.95436f
C2627 FS_P_BLEED_5 HS_N 0.02161f
C2628 TERM_ENABLE FS_N_BLEED_2 0.01311f
C2629 TERM_ENABLE PULLUP_N_GATE 0.23871f
C2630 HS_P_12 PAD_N 0.2517f
C2631 FS_PB_BLEED_1 HS_PBIAS 0.01803f
C2632 HS_N_2 HS_P_13 0.05322f
C2633 TERM_GATE_P_BLEED_0 HS_N_13 0.03931f
C2634 TERM_OR_N_NS HS_PBIAS 0.0879f
C2635 TRIM_N_0_R TERM_TRIM0 8.29568f
C2636 TERM_ENABLE HS_N_8 0.08224f
C2637 PULLUP_P_BLEED_1 HS_N 0.02215f
C2638 PULLUP_N_OUT TRIM_P_2_R 0.0509f
C2639 FS_PB_BLEED_5 TERM_TRIM1 0.04303f
C2640 TERM_N_R PULLUP_N_BLEED_6 0.334f
C2641 TERM_OR_N_B HS_PBIAS 0.09139f
C2642 TRIM_N_1_R TRIM_P_0_R 0.50447f
C2643 HS_N PULLUP_N_BLEED_1 0.0661f
C2644 FS_NB_BLEED_3 FS_NB_BLEED_2 0.06051f
C2645 PULLUP_N_WELL TERM_TRIM1 0.16183f
C2646 FS_P_OUT HS_N 38.6553f
C2647 HS_P_8 HS_N_5 0.03489f
C2648 FS_LOW_P FS_LOW_N 0.11198p
C2649 FS_N_WELL FS_N_GATE 0.10052p
C2650 TERM_P_R HS_N_4 0.09381f
C2651 FS_N_WELL FS_NB_BLEED_2 0
C2652 FS_PB_BLEED_2 TERM_ENABLE 0.00533f
C2653 HS_P_6 FS_LOW_P 0.08441f
C2654 TERM_GATE_N PULLDOWN_P 3.5318f
C2655 HS_P_4 HS_N_6 0.03738f
C2656 TERM_TRIM0 HS_N_10 0.04835f
C2657 HS_N_8 HS_P_8 0.12555f
C2658 FS_LOW_P HS_N_3 0.08963f
C2659 FS_N_GATE TERM_TRIM0 0.28199f
C2660 DIV_N LS_SLOW 0.00778f
C2661 TRIM_P_1_R HS_N_7 0
C2662 TERM_LSA_GATE_P TRIM_N_0_R 0.09162f
C2663 HS_N_2 HS_PBIAS 2.89631f
C2664 FS_LOW_N DIV_ENABLE 0.04461f
C2665 HS_PBIAS PULLUP_P_BLEED_0 0.05271f
C2666 HS_P_6 DIV_ENABLE 0.03996f
C2667 PULLDOWN_N_R PULLUP_N_BLEED_5 0.03764f
C2668 FS_P_BLEED_6 HS_N_2 0.03753f
C2669 PULLUP_P_BLEED_3 PULLDOWN_P_R 0.11369f
C2670 HS_N_11 TERM_TRIM0 0.04831f
C2671 PULLUP_N_OUT TERM_GATE_P 0.23703f
C2672 LS_SLOW FS_NB_GATE 1.86837f
C2673 PULLUP_P PULLUP_N_BLEED_1 0.07012f
C2674 LS_SLOW HS_N_1 0.08005f
C2675 HS_N_3 DIV_ENABLE 0.08392f
C2676 HS_P_1 PULLUP_N_OUT 0.04478f
C2677 FS_P_GATE HS_N_4 0.2337f
C2678 HS_N_5 HS_N_6 0.15317p
C2679 PULLUP_P_OUT DIV_N 0
C2680 TERM_GATE_P_BLEED_0 FS_P_OUT 0.3568f
C2681 TERM_LSA_GATE_P HS_N_10 0.05893f
C2682 TERM_OR_P_S HS_N_4 0.02404f
C2683 TERM_GATE_P HS_P_3 0.15581f
C2684 HS_P_6 TRIM_P_0_R 0.04808f
C2685 HS_N_2 HS_P_11 0.03089f
C2686 HS_P_1 HS_P_3 0.0286f
C2687 TERM_GATE_N HS_PBIAS 0.28103f
C2688 PULLDOWN_N_R PULLUP_P_GATE 0.17983f
C2689 DIV_LOW_P TERM_TRIM2 0.11245f
C2690 HS_N_8 HS_N_6 0.04946f
C2691 PULLUP_P_OUT HS_N_1 0.03489f
C2692 FS_LOW_P HS_N_12 0.08963f
C2693 PULLUP_P_BLEED_2 PULLDOWN_P 0
C2694 TERM_LSA_GATE_P HS_N_11 0.05893f
C2695 HS_N_3 TRIM_P_0_R 0.04808f
C2696 HS_P PULLUP_N_BLEED_3 0.1239f
C2697 PULLUP_N PULLDOWN_N 0.05244f
C2698 FS_LOW_P HS_P_9 0.10622f
C2699 TERM_N_R FS_NB_BLEED_6 0.07012f
C2700 HS_P_0 FS_P_OUT 0.09146f
C2701 DIV_P BYPASS_ENABLE 0.05408f
C2702 VCM_LOW_OK LS_SLOW 5.93431f
C2703 HS_P LS_SLOW 0.02995f
C2704 VCM_LOW_OK HS_P_5 0.12867f
C2705 FS_HIGH_P PULLDOWN_P 0.04316f
C2706 HS_P HS_P_5 5.01638f
C2707 HS_N_12 DIV_ENABLE 0.08392f
C2708 PULLUP_P_BLEED_5 TERM_TRIM0 0.02029f
C2709 FS_P_BLEED_4 HS_N_2 0.03931f
C2710 FS_PB_BLEED_1 PULLDOWN_P_R 0.11369f
C2711 FS_PB_BLEED_6 FS_PB_BLEED_5 0.88599f
C2712 TERM_OR_N_S TERM_VCM 0.03546f
C2713 PULLDOWN_P_R TERM_OR_N_NS 0
C2714 HS_P_9 DIV_ENABLE 0.05087f
C2715 TERM_OR_N_B FS_N_OUT 0.05082f
C2716 FS_HIGH_P FS_P_WELL 4.13562f
C2717 PULLDOWN_P_R TERM_OR_N_B 0.00164f
C2718 TRIM_N_0_R TERM_OR_P_B 0.06737f
C2719 TERM_VCM TERM_P_R 25.1212f
C2720 PULLUP_P_BLEED_3 PULLUP_P_WELL 0
C2721 PULLUP_P_OUT HS_P 0.03526f
C2722 PULLUP_P_OUT VCM_LOW_OK 0.18573f
C2723 PAD_P HS_P_8 1.16385f
C2724 TERM_OR_N_B LS_SLOW_B 0.15206f
C2725 TERM_GATE_P HS_N_13 0.1056f
C2726 HS_N_12 TRIM_P_0_R 0.04885f
C2727 DIV_LOW_P DIV_P 0.11082f
C2728 HS_P_12 TERM_GATE_P_BLEED_1 0.04425f
C2729 HS_P_9 TRIM_P_0_R 0.05898f
C2730 PULLUP_P_BLEED_2 HS_PBIAS 0.09581f
C2731 HS_P_1 HS_N_13 0.03489f
C2732 HS_N_2 FS_N_OUT 0.06167f
C2733 TERM_N_R FS_PB_BLEED_3 0.06024f
C2734 PULLUP_P_BLEED_0 FS_N_OUT 0.06398f
C2735 DIV_N HS_N_7 0.04218f
C2736 PULLDOWN_P_R HS_N_2 0.05893f
C2737 TERM_OR_N_S TRIM_N_2_R 0.04677f
C2738 HS_P_2 TERM_TRIM1 0.02414f
C2739 PULLDOWN_P_R PULLUP_P_BLEED_0 0.05251f
C2740 TERM_OR_P_B HS_N_10 0.05855f
C2741 FS_N_WELL FS_N_BLEED_5 1.59497f
C2742 FS_HIGH_P HS_PBIAS 0.15434f
C2743 TERM_P_R TRIM_N_2_R 0.15295f
C2744 HS_N_1 HS_N_7 0.0739f
C2745 FS_HIGH_P FS_P_BLEED_6 0.42432f
C2746 PULLDOWN_N_R TERM_TRIM1 0.10973f
C2747 FS_P_GATE TERM_VCM 0.19692f
C2748 LS_SLOW_B PULLUP_P_BLEED_0 0.05399f
C2749 PULLUP_N_BLEED_2 HS_N 0.02215f
C2750 HS_N_11 TERM_OR_P_B 0.05851f
C2751 TERM_TRIM0 FS_N_BLEED_5 0.04477f
C2752 TERM_OR_P_S TERM_VCM 0.11282f
C2753 PAD_P HS_N_6 2.18109f
C2754 TERM_TRIM2 TRIM_N_0_R 0.04231f
C2755 TERM_GATE_N FS_N_OUT 0.17648f
C2756 DIV_N FS_PB_BLEED_5 0.10151f
C2757 TERM_ENABLE PULLDOWN_N 0.06103f
C2758 FS_PB_BLEED_1 PULLUP_P_WELL 0
C2759 FS_P_OUT TERM_GATE_P 0.28786f
C2760 FS_NB_GATE FS_N_BLEED_1 0.08788f
C2761 TERM_GATE_N LS_SLOW_B 0.1177f
C2762 HS_P_1 FS_P_OUT 0.05462f
C2763 FS_PB_BLEED_5 HS_N_1 0.03931f
C2764 FS_P_GATE TRIM_N_2_R 0.14118f
C2765 VCM_LOW_OK HS_N_7 0.08296f
C2766 HS_P HS_N_7 0.33458f
C2767 TERM_OR_P_S TRIM_N_2_R 0.03905f
C2768 FS_NB_GATE PULLUP_N_WELL 0.08092f
C2769 TERM_TRIM2 FS_N_GATE 0.19079f
C2770 TERM_P_R HS_N 0.33076f
C2771 HS_P_2 TRIM_P_1_R 0.05049f
C2772 LS_SLOW VDD 9.71878f
C2773 HS_P_4 FS_LOW_P 0.08441f
C2774 HS_N_0 PULLDOWN_P 0.06787f
C2775 VDD HS_P_5 5.81206f
C2776 a_42245_90628# a_41005_131545# 0.01301f
C2777 TERM_ENABLE TERM_OR_N_NS 0.002f
C2778 FS_HIGH_P FS_P_BLEED_4 0.17615f
C2779 HS_N_2 PULLUP_P_WELL 0.11473f
C2780 TERM_ENABLE TERM_OR_N_B 3.96701f
C2781 PULLUP_P_WELL PULLUP_P_BLEED_0 4.55081f
C2782 PULLDOWN_N_R TRIM_P_1_R 0.08484f
C2783 HS_N_0 FS_P_WELL 1.80158f
C2784 PULLUP_P_BLEED_3 HS_N_6 0
C2785 TRIM_N_1_R LS_SLOW 0.08491f
C2786 TRIM_N_1_R HS_P_5 0.02404f
C2787 TRIM_P_1_R PAD_N 0.027f
C2788 HS_P_4 DIV_ENABLE 0.03996f
C2789 HS_P FS_N_BLEED_1 0.00212f
C2790 HS_N_4 TERM_TRIM0 0.04808f
C2791 TERM_LSA_GATE_N VDD 5.3365f
C2792 VCM_LOW_OK FS_PB_BLEED_5 1.57385f
C2793 HS_P FS_PB_BLEED_5 0.03931f
C2794 PULLUP_P_BLEED_2 PULLDOWN_P_R 0.00257f
C2795 PULLUP_P_OUT VDD 4.44706f
C2796 PULLDOWN_N_R TERM_OR_N_PLS 0.0401f
C2797 a_53878_131545# a_53878_132105# 0.0346f
C2798 HS_P PULLUP_N_WELL 0.29178f
C2799 HS_N_9 TERM_N_R 0.0592f
C2800 TERM_ENABLE HS_N_2 0.02404f
C2801 TERM_P_R PULLUP_P 0.22987f
C2802 FS_HIGH_P FS_N_OUT 0.23648f
C2803 FS_P_GATE HS_N 0.35607f
C2804 HS_P_12 PULLUP_N_OUT 0.07935f
C2805 DIV_P HS_N_10 0.04369f
C2806 TRIM_N_1_R TERM_LSA_GATE_N 0.07487f
C2807 FS_LOW_P HS_N_5 0.08963f
C2808 TERM_ENABLE PULLUP_P_BLEED_0 0.06105f
C2809 FS_HIGH_P PULLDOWN_P_R 0.1197f
C2810 PULLUP_P_OUT TRIM_N_1_R 0.06695f
C2811 TERM_OR_P_S HS_N 0.03037f
C2812 TERM_GATE_P_BLEED_0 TERM_P_R 0.00257f
C2813 HS_P_4 TRIM_P_0_R 0.04808f
C2814 FS_LOW_P PULLUP_N_GATE 0.05243f
C2815 HS_P_12 HS_P_3 0.08462f
C2816 HS_N_0 HS_PBIAS 5.90003f
C2817 DIV_P HS_N_11 0.04369f
C2818 FS_HIGH_P LS_SLOW_B 0.05416f
C2819 FS_LOW_P HS_N_8 0.08963f
C2820 TERM_TRIM2 PULLUP_P_BLEED_5 0.00333f
C2821 HS_N_4 TERM_LSA_GATE_P 0.05893f
C2822 HS_N_5 DIV_ENABLE 0.08392f
C2823 HS_N_0 FS_P_BLEED_6 0.0388f
C2824 HS_P_8 HS_N_2 0.03489f
C2825 LS_SLOW FS_LOW_N 0.05955f
C2826 PULLUP_P_WELL FS_PB_BLEED_4 0
C2827 PULLUP_N_GATE DIV_ENABLE 0
C2828 LS_SLOW FS_NB_CONTROL_LS 0.05195f
C2829 HS_P_0 TERM_P_R 0.15888f
C2830 TERM_GATE_N TERM_ENABLE 0.18012f
C2831 HS_P_6 LS_SLOW 0.07769f
C2832 FS_PB_BLEED_1 HS_N_6 0
C2833 HS_P_6 HS_P_5 45.6605f
C2834 HS_N_6 TERM_OR_N_NS 0.00351f
C2835 HS_N_8 DIV_ENABLE 0.08392f
C2836 TERM_GATE_N_BLEED_1 HS_N_1 0.04023f
C2837 FS_N_BLEED_4 FS_N_BLEED_5 0.97237f
C2838 TERM_OR_N_B HS_N_6 0.04808f
C2839 PULLDOWN_P PULLUP_N_BLEED_4 0.087f
C2840 HS_P_7 TERM_VCM 0.22076f
C2841 HS_N_5 TRIM_P_0_R 0.04808f
C2842 LS_SLOW HS_N_3 0.02404f
C2843 RX_P DIV_ENABLE 0.88297f
C2844 PULLUP_N_BLEED_0 TERM_VCM 0.13638f
C2845 PULLUP_P_OUT HS_P_6 0.05276f
C2846 FS_PB_GATE PULLUP_P_GATE 0.12901f
C2847 PULLUP_P_BLEED_2 PULLUP_P_WELL 0.00151f
C2848 HS_N_8 TRIM_P_0_R 0.04808f
C2849 VDD HS_N_7 6.55725f
C2850 TERM_P_R PULLUP_P_BLEED_6 0.01857f
C2851 FS_N_WELL TERM_VCM 1.37443f
C2852 FS_P_GATE FS_PB_CONTROL_S 0.00226f
C2853 HS_N_6 HS_N_2 0
C2854 HS_P_12 HS_N_13 0.00133f
C2855 FS_N_CONTROL_S LS_SLOW_B 0.66433f
C2856 PULLUP_P_OUT HS_N_3 0.03489f
C2857 HS_N_6 PULLUP_P_BLEED_0 0.03931f
C2858 DIV_N PULLDOWN_N_R 0.05218f
C2859 FS_HIGH_P PULLUP_P_WELL 0.2756f
C2860 TRIM_N_1_R HS_N_7 0.04808f
C2861 TERM_VCM DIV_LOW_N 0.01585f
C2862 TERM_OR_P_S HS_P_0 0.03037f
C2863 HS_P TERM_GATE_N_BLEED_1 0.11051f
C2864 TERM_TRIM2 FS_N_BLEED_5 0.04294f
C2865 HS_N_0 FS_P_BLEED_4 0.03931f
C2866 HS_P_7 TRIM_N_2_R 0.03626f
C2867 HS_P_2 HS_N_1 0.03247f
C2868 TERM_P_R TRIM_P_2_R 0.16075f
C2869 TERM_VCM TERM_TRIM0 15.8199f
C2870 FS_NB_BLEED_6 BYPASS_ENABLE 0.00766f
C2871 PULLUP_N_OUT PULLUP_P_GATE 5.14371f
C2872 DIV_N PAD_N 0.68859f
C2873 PULLDOWN_N_R FS_NB_GATE 0.58649f
C2874 PULLDOWN_P_R PULLUP_P_CONTROL_S 0.02198f
C2875 PULLDOWN_N_R HS_N_1 0.06832f
C2876 LS_SLOW HS_N_12 0.07364f
C2877 HS_N_9 HS_P_10 0.03125f
C2878 PULLUP_N_BLEED_4 HS_PBIAS 0.01803f
C2879 HS_N_4 TERM_OR_P_B 0.05828f
C2880 LS_SLOW HS_P_9 0.03494f
C2881 RX_N PAD_N 9.45181f
C2882 HS_P_9 HS_P_5 0.04211f
C2883 FS_PB_BLEED_5 VDD 0.54412f
C2884 PAD_N HS_N_1 1.16218f
C2885 FS_PB_GATE FS_PB_CONTROL_LS 0.33658f
C2886 PULLUP_P_CONTROL_S LS_SLOW_B 0
C2887 TERM_GATE_N HS_N_6 0.14786f
C2888 FS_HIGH_P TERM_ENABLE 0.05873f
C2889 PULLUP_N_WELL FS_NB_BLEED_0 0
C2890 PULLUP_N_WELL VDD 19.6718f
C2891 HS_N_0 FS_N_OUT 0.06167f
C2892 TERM_VCM TERM_LSA_GATE_P 9.62161f
C2893 TRIM_N_1_R FS_PB_BLEED_5 0.04163f
C2894 DIV_LOW_N TRIM_N_2_R 0.00685f
C2895 PULLUP_P_OUT HS_N_12 0.03489f
C2896 HS_N_0 PULLDOWN_P_R 0.05997f
C2897 TERM_TRIM0 TRIM_N_2_R 0.02497f
C2898 HS_P_2 VCM_LOW_OK 0.08296f
C2899 PULLUP_P_OUT HS_P_9 0.00174f
C2900 TERM_N_R BYPASS_ENABLE 0.00444f
C2901 HS_P_2 HS_P 7.08425f
C2902 TERM_P_R TERM_GATE_P 16.1409f
C2903 PAD_P DIV_ENABLE 0.15699f
C2904 TERM_OR_P_S TRIM_P_2_R 0.04415f
C2905 HS_N_0 LS_SLOW_B 0.04331f
C2906 FS_LOW_N HS_N_7 0.0855f
C2907 HS_P_12 FS_P_OUT 0.05462f
C2908 HS_P_1 TERM_P_R 0.132f
C2909 HS_P_7 HS_N 0.15132f
C2910 VCM_LOW_OK PULLDOWN_N_R 0.13702f
C2911 HS_P_6 HS_N_7 0.00133f
C2912 HS_P PULLDOWN_N_R 0.04198f
C2913 FS_P_WELL HS_P_13 0.00958f
C2914 FS_PB_GATE TERM_TRIM1 0.68068f
C2915 FS_NB_BLEED_1 PULLUP_N_WELL 0
C2916 HS_P PAD_N 1.85908f
C2917 TERM_N_R TERM_GATE_N_BLEED_0 0.00257f
C2918 FS_NB_BLEED_5 FS_NB_BLEED_4 0.04499f
C2919 ESD_RAIL a_53878_133785# 0.53942f
C2920 HS_N_3 HS_N_7 0.02877f
C2921 TERM_LSA_GATE_P TRIM_N_2_R 0.05813f
C2922 PAD_P TRIM_P_0_R 4.75695f
C2923 FS_N_WELL HS_N 2.74317f
C2924 TERM_N_R DIV_LOW_P 0.04826f
C2925 PULLUP_P_GATE HS_N_13 0.04808f
C2926 PULLDOWN_P HS_PBIAS 0.46722f
C2927 PULLUP_N_OUT TERM_TRIM1 0.11556f
C2928 FS_N_CONTROL_S TERM_ENABLE 0.14276f
C2929 PULLUP_P_BLEED_2 HS_N_6 0.04809f
C2930 PULLUP_P_CONTROL_S PULLUP_P_WELL 0.11312f
C2931 TERM_VCM TERM_OR_P_NS 0.00135f
C2932 FS_P_WELL HS_PBIAS 2.82452f
C2933 HS_N TERM_TRIM0 0.06822f
C2934 TERM_OR_P_S TERM_GATE_P 0.0046f
C2935 HS_PBIAS HS_P_13 6.80053f
C2936 TERM_TRIM1 HS_P_3 0.02413f
C2937 FS_LOW_N PULLUP_N_WELL 0.11777f
C2938 TERM_OR_P_S HS_P_1 0.02404f
C2939 FS_P_WELL FS_P_BLEED_6 0
C2940 FS_HIGH_P HS_N_6 0.08792f
C2941 FS_NB_BLEED_3 PULLUP_P 0.82704f
C2942 FS_PB_BLEED_5 HS_N_3 0.03931f
C2943 HS_N_0 PULLUP_P_WELL 0.2469f
C2944 FS_N_WELL PULLUP_P 2.21492f
C2945 HS_N_12 HS_N_7 0.02955f
C2946 TERM_VCM TERM_OR_P_B 0.11999f
C2947 TERM_ENABLE PULLUP_P_CONTROL_S 0.02751f
C2948 HS_P_9 HS_N_7 0.02404f
C2949 DIV_P HS_N_4 0.04369f
C2950 FS_P_WELL HS_P_11 0.01032f
C2951 TERM_LSA_GATE_P HS_N 0.0716f
C2952 HS_P_11 HS_P_13 0.0909f
C2953 PULLUP_P DIV_LOW_N 0.82462f
C2954 PULLUP_P_BLEED_1 PULLUP_P_GATE 0.00236f
C2955 HS_P_7 HS_P_0 0.03477f
C2956 TERM_TRIM0 PULLUP_P 0.04377f
C2957 TERM_VCM FS_N_BLEED_4 0.13629f
C2958 TERM_TRIM1 FS_HIGH_N 0.02404f
C2959 PULLUP_N PULLUP_N_BLEED_4 0.93147f
C2960 TERM_N_R DIFF_ENABLE 5.28693f
C2961 FS_N_GATE FS_NB_CONTROL_S 0.02075f
C2962 FS_P_BLEED_6 HS_PBIAS 0.09353f
C2963 HS_P_4 LS_SLOW 0.07619f
C2964 HS_N_0 TERM_ENABLE 0.07886f
C2965 HS_P_4 HS_P_5 47.0377f
C2966 HS_P FS_N_BLEED_0 0.1239f
C2967 PULLUP_N_OUT TRIM_P_1_R 0.10697f
C2968 FS_LOW_P TERM_OR_N_B 0.07304f
C2969 FS_PB_BLEED_5 HS_N_12 0.03931f
C2970 TERM_OR_P_B TRIM_N_2_R 0.06038f
C2971 FS_PB_GATE FS_PB_BLEED_6 0.04958f
C2972 HS_N_13 TERM_TRIM1 0.02404f
C2973 HS_P_2 VDD 6.22676f
C2974 FS_P_WELL FS_P_BLEED_4 0.06232f
C2975 TRIM_P_1_R HS_P_3 0.04987f
C2976 HS_P_11 HS_PBIAS 2.43225f
C2977 FS_NB_BLEED_6 FS_NB_BLEED_2 0.01434f
C2978 HS_P_0 TERM_TRIM0 0.05883f
C2979 TERM_N_R TRIM_N_0_R 0.18773f
C2980 PULLDOWN_N_R VDD 2.86821f
C2981 PULLUP_N_OUT TERM_OR_N_PLS 0
C2982 TERM_TRIM2 TERM_VCM 0.20628p
C2983 TERM_OR_N_B DIV_ENABLE 0
C2984 HS_N_0 HS_P_8 0.03489f
C2985 TERM_GATE_P_BLEED_0 TERM_LSA_GATE_P 0.00178f
C2986 FS_P_BLEED_1 VCM_LOW_OK 0.01004f
C2987 HS_P_2 TRIM_N_1_R 0.02404f
C2988 FS_LOW_P HS_N_2 0.21712f
C2989 PULLDOWN_P PULLUP_N_CONTROL_S 0.03073f
C2990 TRIM_N_0_R FS_PB_BLEED_3 0.00148f
C2991 PULLDOWN_P FS_N_OUT 0.7635f
C2992 FS_P_BLEED_0 FS_P_WELL 1.94995f
C2993 FS_N_GATE FS_N_BLEED_6 0.04958f
C2994 PULLUP_N_BLEED_3 PULLUP_N_GATE 0
C2995 PULLDOWN_P PULLDOWN_P_R 4.93498f
C2996 HS_N_5 HS_P_5 0.06806f
C2997 LS_SLOW HS_N_5 0.07936f
C2998 FS_LOW_P PULLUP_P_BLEED_0 0.07136f
C2999 TRIM_N_1_R PULLDOWN_N_R 0.08099f
C3000 FS_P_WELL FS_N_OUT 1.21642f
C3001 LS_SLOW FS_N_BLEED_2 0.06384f
C3002 LS_SLOW PULLUP_N_GATE 3.11927f
C3003 TRIM_N_1_R PAD_N 3.04326f
C3004 HS_P TERM_GATE_P_BLEED_1 0.00212f
C3005 VCM_LOW_OK TERM_GATE_P_BLEED_1 0.14164f
C3006 FS_P_WELL PULLDOWN_P_R 2.21813f
C3007 PULLDOWN_P PULLUP_N 5.71742f
C3008 PULLDOWN_P LS_SLOW_B 0.00507f
C3009 LS_SLOW HS_N_8 0.08279f
C3010 TERM_N_R HS_N_10 0.06034f
C3011 PULLDOWN_P_R HS_P_13 0.0676f
C3012 HS_N_2 DIV_ENABLE 0.08392f
C3013 FS_P_BLEED_4 HS_PBIAS 0.05271f
C3014 PULLUP_P_BLEED_6 TERM_TRIM0 0.02536f
C3015 HS_N_8 HS_P_5 0.02404f
C3016 HS_N_3 TERM_GATE_N_BLEED_1 0.04313f
C3017 HS_P_0 TERM_LSA_GATE_P 0.0716f
C3018 DIV_ENABLE PULLUP_P_BLEED_0 0.01375f
C3019 TERM_N_R FS_N_GATE 0.33526f
C3020 HS_N TERM_OR_P_B 0.07137f
C3021 FS_P_BLEED_6 FS_P_BLEED_4 0.00131f
C3022 TERM_TRIM2 TRIM_N_2_R 5.28145f
C3023 PULLUP_P_OUT HS_N_5 0.03489f
C3024 FS_P_WELL LS_SLOW_B 1.34807f
C3025 LS_SLOW_B HS_P_13 0.04331f
C3026 TERM_N_R HS_N_11 0.05996f
C3027 TERM_TRIM1 PULLUP_N_BLEED_1 0.04304f
C3028 FS_PB_BLEED_2 LS_SLOW 0.05941f
C3029 TERM_GATE_N FS_LOW_P 0.2123f
C3030 TRIM_P_2_R TERM_TRIM0 0.02908f
C3031 HS_N_0 HS_N_6 0.03911f
C3032 FS_P_OUT TERM_TRIM1 0.23991f
C3033 FS_P_BLEED_0 HS_PBIAS 0.01397f
C3034 TERM_VCM DIV_P 0.82767f
C3035 PULLUP_P_OUT HS_N_8 0.0351f
C3036 TRIM_P_1_R HS_N_13 0
C3037 HS_P_7 TERM_GATE_P 0.15354f
C3038 HS_N_2 TRIM_P_0_R 0.04855f
C3039 FS_PB_GATE DIV_N 0.07703f
C3040 PULLUP_N_CONTROL_S HS_PBIAS 0.09332f
C3041 HS_P_2 HS_P_6 0.03898f
C3042 HS_P_7 HS_P_1 0.03559f
C3043 HS_PBIAS FS_N_OUT 1.55645f
C3044 PULLDOWN_P_R HS_PBIAS 0.42323f
C3045 TERM_GATE_N DIV_ENABLE 0.02059f
C3046 PULLDOWN_N_R FS_LOW_N 0.05905f
C3047 PULLUP_P_OUT FS_PB_BLEED_2 0.0565f
C3048 PULLDOWN_N_R FS_NB_CONTROL_LS 0.00267f
C3049 HS_P_6 PULLDOWN_N_R 0.07217f
C3050 HS_P_2 HS_N_3 0.02404f
C3051 HS_P_12 TERM_P_R 0.14555f
C3052 FS_PB_GATE HS_N_1 0.29465f
C3053 TERM_GATE_N_BLEED_1 HS_N_12 0.03973f
C3054 PULLUP_N HS_PBIAS 0.02682f
C3055 LS_SLOW_B HS_PBIAS 0.41801f
C3056 TRIM_P_2_R TERM_LSA_GATE_P 0.06796f
C3057 DIV_N PULLUP_N_OUT 0
C3058 HS_P_6 PAD_N 0.34177f
C3059 PULLDOWN_N_R HS_N_3 0.02404f
C3060 FS_NB_CONTROL_S FS_N_BLEED_5 0
C3061 TERM_GATE_P TERM_TRIM0 0.00224f
C3062 FS_PB_BLEED_0 HS_N_1 0.04023f
C3063 HS_N_3 PAD_N 1.69605f
C3064 PULLUP_N_OUT FS_NB_GATE 0.651f
C3065 PULLDOWN_P_R HS_P_11 0.06095f
C3066 TERM_N_R PULLUP_P_BLEED_5 0.06024f
C3067 PULLUP_N_OUT HS_N_1 0.04908f
C3068 HS_P_1 TERM_TRIM0 0.02404f
C3069 FS_P_BLEED_4 FS_P_BLEED_2 0.25341f
C3070 HS_P_0 TERM_OR_P_B 0.07385f
C3071 HS_P_12 FS_P_GATE 0.00912f
C3072 HS_P_3 HS_N_1 0.02599f
C3073 HS_N_5 HS_N_7 0.07798f
C3074 FS_P_BLEED_0 FS_P_BLEED_4 0.00257f
C3075 FS_PB_GATE VCM_LOW_OK 1.26425f
C3076 FS_P_BLEED_1 VDD 0
C3077 FS_PB_GATE HS_P 0.30689f
C3078 HS_N_9 TRIM_N_0_R 0.03489f
C3079 HS_P_2 HS_N_12 0.02482f
C3080 PULLDOWN_P TERM_ENABLE 0.03372f
C3081 PAD_P LS_SLOW 0.31756f
C3082 FS_HIGH_P FS_LOW_P 12.9339f
C3083 TERM_OR_P_S HS_P_12 0.02404f
C3084 PAD_P HS_P_5 1.21805f
C3085 TERM_P_R PULLUP_N_BLEED_5 0
C3086 TERM_LSA_GATE_P TERM_GATE_P 0.20457f
C3087 HS_P_2 HS_P_9 0
C3088 FS_P_BLEED_4 FS_N_OUT 0.06398f
C3089 HS_P_10 HS_N_10 0.09288f
C3090 TERM_TRIM2 PULLUP_P 0.04377f
C3091 TERM_GATE_P TERM_GATE_P_BLEED_2 0.08298f
C3092 HS_N_8 HS_N_7 0.15104p
C3093 PULLDOWN_P_R FS_P_BLEED_4 0.05209f
C3094 PULLDOWN_N_R HS_N_12 0.06159f
C3095 HS_P_1 TERM_LSA_GATE_P 0.05893f
C3096 TERM_ENABLE FS_P_WELL 2.38297f
C3097 FS_PB_BLEED_0 HS_P 0.11051f
C3098 TERM_ENABLE HS_P_13 0.07638f
C3099 PULLDOWN_N_R HS_P_9 5.58682f
C3100 FS_N_BLEED_6 FS_N_BLEED_5 0.96553f
C3101 DIV_P HS_N 0.13026f
C3102 FS_HIGH_P DIV_ENABLE 4.94444f
C3103 VCM_LOW_OK PULLUP_N_OUT 0.10787f
C3104 PULLUP_P_WELL HS_PBIAS 0.6222f
C3105 PAD_N HS_N_12 1.22534f
C3106 HS_P PULLUP_N_OUT 0.09364f
C3107 HS_P_10 HS_N_11 0.1403f
C3108 PULLUP_P_OUT PAD_P 0.47575f
C3109 FS_NB_GATE FS_HIGH_N 5.80481f
C3110 HS_P_9 PAD_N 11.1927f
C3111 LS_SLOW_B FS_P_BLEED_4 0.06307f
C3112 HS_N_9 HS_N_10 0.04457f
C3113 HS_N_9 FS_N_GATE 0.00226f
C3114 FS_PB_BLEED_5 HS_N_5 0.03931f
C3115 FS_P_BLEED_0 PULLDOWN_P_R 0.10683f
C3116 DIV_N HS_N_13 0.04218f
C3117 HS_P HS_P_3 1.89093f
C3118 VCM_LOW_OK HS_P_3 0.08296f
C3119 LS_SLOW_B FS_P_BLEED_2 0.83369f
C3120 ESD_RAIL a_44789_117064# 16.8853f
C3121 TERM_N_R FS_N_BLEED_5 0.06307f
C3122 TERM_P_R PULLUP_P_GATE 0.20614f
C3123 FS_N_BLEED_1 FS_N_BLEED_2 0.3435f
C3124 TRIM_P_2_R TERM_OR_P_B 0.07519f
C3125 HS_N_9 HS_N_11 0.03511f
C3126 HS_P_8 HS_P_13 0.17078f
C3127 PULLDOWN_P_R FS_N_OUT 0.06167f
C3128 HS_P_0 TERM_TRIM2 0.03607f
C3129 FS_PB_BLEED_5 HS_N_8 0.03931f
C3130 PULLUP_N_WELL PULLUP_N_GATE 43.7957f
C3131 TERM_ENABLE HS_PBIAS 0.72844f
C3132 HS_N_13 HS_N_1 0.09085f
C3133 PULLUP_N PULLUP_N_CONTROL_S 1.71031f
C3134 PULLUP_P_BLEED_3 LS_SLOW 0.18014f
C3135 LS_SLOW_B FS_N_OUT 0.32954f
C3136 FS_PB_BLEED_2 FS_PB_BLEED_5 0.1071f
C3137 HS_P FS_HIGH_N 0.1715f
C3138 PULLDOWN_P HS_N_6 0.06787f
C3139 TERM_TRIM2 PULLUP_P_BLEED_6 0.06152f
C3140 HS_P_8 HS_PBIAS 3.88244f
C3141 DIV_N FS_P_BLEED_5 0
C3142 LS_SLOW PULLDOWN_N 0.05905f
C3143 TERM_ENABLE HS_P_11 0.03248f
C3144 FS_PB_CONTROL_LS TERM_P_R 0.0414f
C3145 PULLUP_P_BLEED_1 DIV_N 0
C3146 FS_P_WELL HS_N_6 0.96699f
C3147 TERM_GATE_P TERM_OR_P_B 4.86054f
C3148 HS_N_6 HS_P_13 0.03089f
C3149 TERM_VCM PULLUP_N_BLEED_6 0.00196f
C3150 BYPASS_ENABLE DIFF_ENABLE 6.50064f
C3151 HS_P_6 TERM_GATE_P_BLEED_1 0.03089f
C3152 HS_P_1 TERM_OR_P_B 0.07026f
C3153 TERM_TRIM2 TRIM_P_2_R 3.653f
C3154 VCM_LOW_OK HS_N_13 0.08356f
C3155 HS_P_0 DIV_P 0.05049f
C3156 DIV_N FS_P_OUT 0.06205f
C3157 HS_P HS_N_13 0.10647f
C3158 FS_P_BLEED_5 HS_N_1 0
C3159 PAD_P ESD_RAIL 45.941f
C3160 PAD_P HS_N_7 0.08118f
C3161 PULLUP_P_BLEED_1 HS_N_1 0
C3162 TERM_OR_N_S TERM_TRIM1 0.0456f
C3163 RX_N FS_P_OUT 0.00505f
C3164 TERM_N_R HS_N_4 0.05893f
C3165 FS_PB_GATE VDD 30.5044f
C3166 HS_P_8 HS_P_11 0.03867f
C3167 FS_P_OUT HS_N_1 0.72711f
C3168 LS_SLOW TERM_OR_N_NS 0.17619f
C3169 HS_N_0 FS_LOW_P 0.08965f
C3170 FS_NB_BLEED_4 TERM_ENABLE 0.15568f
C3171 FS_PB_BLEED_1 LS_SLOW 0.00564f
C3172 TERM_P_R TERM_TRIM1 0.07944f
C3173 PULLUP_P_BLEED_5 PULLUP_P_BLEED_4 0.03688f
C3174 TERM_ENABLE FS_P_BLEED_4 0.06892f
C3175 PULLUP_P_WELL FS_N_OUT 0.13784f
C3176 LS_SLOW TERM_OR_N_B 3.33875f
C3177 PULLDOWN_P_R PULLUP_P_WELL 0.35883f
C3178 HS_N_6 HS_PBIAS 4.8762f
C3179 HS_N_5 TERM_GATE_N_BLEED_1 0.0458f
C3180 FS_PB_GATE TRIM_N_1_R 0.16287f
C3181 TERM_ENABLE FS_P_BLEED_2 0.16736f
C3182 HS_P_2 HS_P_4 0.00206f
C3183 HS_P_7 HS_P_12 0.05394f
C3184 FS_P_BLEED_6 HS_N_6 0.04603f
C3185 HS_N_0 DIV_ENABLE 1.77856f
C3186 PULLUP_N_OUT VDD 5.97822f
C3187 HS_P TERM_GATE_N_BLEED_2 0.00212f
C3188 LS_SLOW_B PULLUP_P_WELL 0.32953f
C3189 TERM_TRIM2 TERM_GATE_P 0.03184f
C3190 HS_N_8 TERM_GATE_N_BLEED_1 0.05643f
C3191 HS_P_4 PULLDOWN_N_R 0.06544f
C3192 TERM_P_R FS_P_BLEED_3 0.01857f
C3193 DIV_P TRIM_P_2_R 0.03341f
C3194 TERM_OR_N_B TERM_LSA_GATE_N 0.83546f
C3195 LS_SLOW HS_N_2 0.02404f
C3196 TRIM_N_1_R PULLUP_N_OUT 0.09991f
C3197 TERM_ENABLE FS_N_OUT 0.48079f
C3198 VDD HS_P_3 4.3842f
C3199 HS_P_4 PAD_N 0.30613f
C3200 LS_SLOW PULLUP_P_BLEED_0 0.39766f
C3201 TERM_ENABLE PULLDOWN_P_R 0.03754f
C3202 HS_P PULLUP_N_BLEED_1 0.05271f
C3203 VCM_LOW_OK FS_P_OUT 0.74762f
C3204 HS_N_6 HS_P_11 0.03089f
C3205 FS_P_GATE TERM_TRIM1 0.40266f
C3206 HS_P FS_P_OUT 0.96811f
C3207 PULLUP_P_BLEED_3 HS_N_7 0
C3208 HS_P_9 TERM_GATE_P_BLEED_1 0.04573f
C3209 DIV_LOW_P TRIM_N_0_R 0.02708f
C3210 HS_N_0 TRIM_P_0_R 0.05093f
C3211 TRIM_N_1_R HS_P_3 0.02404f
C3212 HS_P_2 HS_N_5 0.05493f
C3213 HS_P_12 TERM_TRIM0 0.02404f
C3214 TERM_ENABLE LS_SLOW_B 15.7649f
C3215 FS_NB_BLEED_6 TERM_VCM 0.0562f
C3216 PULLUP_P_OUT HS_N_2 0.03489f
C3217 HS_P_8 FS_N_OUT 0.06167f
C3218 PULLUP_P_OUT PULLUP_P_BLEED_0 0.0061f
C3219 TERM_GATE_N_BLEED_0 HS_N_10 0
C3220 PULLDOWN_N_R HS_N_5 0.06159f
C3221 PULLDOWN_P_R HS_P_8 0.02414f
C3222 FS_HIGH_N VDD 0.42119f
C3223 HS_P_2 HS_N_8 0.04808f
C3224 TERM_P_R TRIM_P_1_R 0.14653f
C3225 FS_HIGH_N FS_NB_BLEED_0 0.00961f
C3226 TERM_GATE_N LS_SLOW 5.71541f
C3227 DIV_P TERM_GATE_P 0.04411f
C3228 HS_N_5 PAD_N 1.19296f
C3229 HS_N_6 FS_P_BLEED_4 0.03931f
C3230 PULLDOWN_N_R FS_N_BLEED_2 0.00251f
C3231 PULLDOWN_N_R PULLUP_N_GATE 1.45794f
C3232 HS_P_1 DIV_P 0.04275f
C3233 HS_N_11 TERM_GATE_N_BLEED_0 0
C3234 PULLDOWN_N_R HS_N_8 0.06832f
C3235 FS_PB_GATE HS_N_3 0.29305f
C3236 HS_P_12 TERM_LSA_GATE_P 0.05893f
C3237 PULLUP_N_OUT FS_LOW_N 0.04655f
C3238 HS_N_8 PAD_N 1.10091f
C3239 PULLUP_N_OUT FS_NB_CONTROL_LS 0.04276f
C3240 HS_P_6 PULLUP_N_OUT 0.0846f
C3241 TERM_N_R TERM_VCM 18.664f
C3242 HS_P_10 HS_N_4 0.07706f
C3243 TERM_GATE_N TERM_LSA_GATE_N 0.02231f
C3244 HS_N_13 VDD 6.56309f
C3245 FS_P_BLEED_0 HS_N_6 0
C3246 a_53878_133785# a_53878_134345# 0.0346f
C3247 FS_PB_BLEED_2 PULLDOWN_N_R 0.00251f
C3248 FS_PB_BLEED_0 HS_N_3 0.04313f
C3249 FS_PB_BLEED_1 HS_N_7 0
C3250 TERM_OR_N_NS HS_N_7 0.00491f
C3251 TERM_VCM FS_PB_BLEED_3 0.00196f
C3252 RX_P PAD_N 3.07596f
C3253 PULLUP_N_OUT HS_N_3 0.00232f
C3254 HS_P_6 HS_P_3 0.04322f
C3255 TERM_OR_N_B HS_N_7 0.04808f
C3256 TRIM_N_1_R HS_N_13 0.04872f
C3257 PULLDOWN_P_R HS_N_6 0.05893f
C3258 TERM_ENABLE PULLUP_P_WELL 0.52272f
C3259 TERM_OR_P_S TRIM_P_1_R 0.0368f
C3260 HS_N_9 HS_N_4 0.03262f
C3261 HS_N_3 HS_P_3 0.03733f
C3262 HS_N_6 LS_SLOW_B 0
C3263 FS_PB_GATE HS_N_12 0.29391f
C3264 TERM_N_R TRIM_N_2_R 0.18507f
C3265 HS_N_2 HS_N_7 0.02926f
C3266 FS_LOW_N FS_HIGH_N 0.25747f
C3267 PULLUP_P_GATE TERM_TRIM0 0.16054f
C3268 FS_PB_BLEED_3 TRIM_N_2_R 0
C3269 FS_PB_BLEED_1 FS_PB_BLEED_5 0.01067f
C3270 PULLUP_P_BLEED_0 HS_N_7 0.03931f
C3271 FS_NB_CONTROL_LS FS_HIGH_N 0.01342f
C3272 FS_NB_BLEED_6 HS_N 0.06167f
C3273 PULLDOWN_P FS_LOW_P 0.08421f
C3274 FS_PB_BLEED_0 HS_N_12 0.03973f
C3275 FS_HIGH_P LS_SLOW 0.04975f
C3276 PULLUP_N_OUT HS_N_12 0.00119f
C3277 VDD PULLUP_N_BLEED_1 0.57249f
C3278 FS_P_OUT VDD 9.06091f
C3279 FS_NB_CONTROL_S PULLUP_P 0
C3280 FS_LOW_P FS_P_WELL 2.35683f
C3281 PULLUP_N_OUT HS_P_9 0.02846f
C3282 HS_P_2 PAD_P 1.24412f
C3283 FS_LOW_P HS_P_13 0.08452f
C3284 HS_N FS_N_BLEED_6 0.02531f
C3285 FS_LOW_N HS_N_13 0.08505f
C3286 PULLDOWN_P DIV_ENABLE 0.05351f
C3287 TRIM_N_0_R HS_N_10 0.03489f
C3288 HS_P_12 TERM_OR_P_B 0.1077f
C3289 HS_N_12 HS_P_3 0.02482f
C3290 HS_P_4 TERM_GATE_P_BLEED_1 0.03169f
C3291 HS_P_6 HS_N_13 0.03425f
C3292 BYPASS_ENABLE FS_N_BLEED_5 0.00766f
C3293 TRIM_N_1_R FS_P_OUT 0.19273f
C3294 PULLUP_P_OUT FS_HIGH_P 0.09641f
C3295 DIV_N TERM_P_R 0.00818f
C3296 HS_P_9 HS_P_3 0
C3297 PAD_P PULLDOWN_N_R 3.13823f
C3298 TERM_GATE_N HS_N_7 0.14831f
C3299 TERM_ENABLE HS_P_8 0.02404f
C3300 FS_PB_BLEED_5 HS_N_2 0.03931f
C3301 HS_P_7 TERM_TRIM1 0.0525f
C3302 FS_P_WELL DIV_ENABLE 0.10646f
C3303 DIV_ENABLE HS_P_13 0.03996f
C3304 TRIM_N_0_R HS_N_11 0.03489f
C3305 HS_N_3 HS_N_13 0.30894f
C3306 PAD_P PAD_N 67.6343f
C3307 FS_NB_BLEED_6 PULLUP_P 0.0653f
C3308 TERM_N_R HS_N 0.28566f
C3309 FS_PB_CONTROL_LS TERM_TRIM0 0.02846f
C3310 HS_N_6 PULLUP_P_WELL 0.12499f
C3311 FS_NB_GATE TERM_P_R 0.50077f
C3312 TERM_P_R HS_N_1 0.13716f
C3313 PULLUP_N_BLEED_0 TERM_TRIM1 0.12156f
C3314 HS_P_10 TERM_VCM 0.22054f
C3315 a_41005_131825# a_41005_132385# 0.0346f
C3316 FS_LOW_P HS_PBIAS 0.34356f
C3317 FS_N_WELL TERM_TRIM1 1.13931f
C3318 HS_N_5 TERM_GATE_P_BLEED_1 0
C3319 TRIM_P_0_R HS_P_13 0.04808f
C3320 DIV_N FS_P_GATE 0.05519f
C3321 HS_N_11 HS_N_10 0.16901p
C3322 HS_N_9 TERM_VCM 0.2797f
C3323 TERM_TRIM1 DIV_LOW_N 0.00559f
C3324 DIV_ENABLE HS_PBIAS 0.11857f
C3325 TERM_OR_N_S VCM_LOW_OK 2.19702f
C3326 TERM_OR_P_S DIV_N 0.02186f
C3327 TERM_TRIM1 TERM_TRIM0 0.19721p
C3328 TERM_ENABLE HS_N_6 0.06652f
C3329 HS_N_8 TERM_GATE_P_BLEED_1 0.00108f
C3330 FS_LOW_N PULLUP_N_BLEED_1 0.07126f
C3331 TERM_N_R PULLUP_P 0.42327f
C3332 HS_N_12 HS_N_13 0.16726p
C3333 HS_P_6 FS_P_OUT 0.05462f
C3334 PULLUP_P_BLEED_3 PULLDOWN_N_R 0.06464f
C3335 FS_P_GATE HS_N_1 0.23699f
C3336 VCM_LOW_OK TERM_P_R 0.17513f
C3337 FS_LOW_P HS_P_11 0.08684f
C3338 HS_P TERM_P_R 0.20812f
C3339 PULLUP_P_BLEED_2 HS_N_7 0.05151f
C3340 HS_P_9 HS_N_13 0.02464f
C3341 TERM_OR_P_S HS_N_1 0.02404f
C3342 TRIM_N_0_R PULLUP_P_BLEED_5 0.00148f
C3343 LS_SLOW PULLUP_P_CONTROL_S 0.05398f
C3344 FS_PB_BLEED_5 FS_PB_BLEED_4 0.97176f
C3345 FS_P_OUT HS_N_3 0.77052f
C3346 FS_P_BLEED_3 TERM_TRIM0 0.02536f
C3347 a_53878_133225# a_53878_133785# 0.0346f
C3348 HS_P_7 TRIM_P_1_R 0.04858f
C3349 HS_P_8 HS_N_6 0.03489f
C3350 FS_HIGH_P HS_N_7 0.08792f
C3351 HS_N_9 TRIM_N_2_R 0
C3352 HS_P_11 DIV_ENABLE 0.03996f
C3353 PULLDOWN_N_R PULLDOWN_N 5.88794f
C3354 a_43813_117064# ESD_RAIL 5.25092f
C3355 HS_N_0 LS_SLOW 0.07976f
C3356 TERM_N_R HS_P_0 0.05016f
C3357 PULLUP_P_OUT PULLUP_P_CONTROL_S 0.01755f
C3358 FS_LOW_P FS_P_BLEED_4 0.07097f
C3359 a_42245_90628# a_44789_117064# 11.6307f
C3360 HS_N_2 TERM_GATE_N_BLEED_1 0.03931f
C3361 FS_P_BLEED_5 HS_N_12 0
C3362 VCM_LOW_OK FS_P_GATE 46.1439f
C3363 HS_P_12 DIV_P 0.07663f
C3364 HS_P FS_P_GATE 0.24591f
C3365 HS_P_11 TRIM_P_0_R 0.04808f
C3366 PULLUP_P_BLEED_1 HS_N_12 0
C3367 TERM_OR_P_S HS_P 0.03037f
C3368 TERM_OR_P_S VCM_LOW_OK 5.31888f
C3369 HS_P_10 HS_N 0.34498f
C3370 HS_P_4 PULLUP_N_OUT 0.02982f
C3371 TRIM_P_1_R TERM_TRIM0 0.03175f
C3372 FS_P_BLEED_4 DIV_ENABLE 0.01375f
C3373 PULLUP_P_OUT HS_N_0 0.03489f
C3374 FS_HIGH_P FS_PB_BLEED_5 0.16851f
C3375 FS_P_OUT HS_N_12 0.71987f
C3376 FS_PB_BLEED_1 PULLDOWN_N_R 0.06464f
C3377 PULLDOWN_N_R TERM_OR_N_NS 0.04218f
C3378 HS_P_9 FS_P_OUT 0.10516f
C3379 FS_HIGH_P PULLUP_N_WELL 0.22707f
C3380 PULLDOWN_N_R TERM_OR_N_B 0.11973f
C3381 FS_LOW_P FS_N_OUT 0.44088f
C3382 HS_P_4 HS_P_3 47.6404f
C3383 FS_PB_GATE HS_N_5 0.29625f
C3384 FS_LOW_P PULLDOWN_P_R 0.20334f
C3385 FS_N_BLEED_3 TERM_P_R 0.04893f
C3386 HS_N_9 HS_N 5.92574f
C3387 TERM_GATE_N TERM_GATE_N_BLEED_1 0.00178f
C3388 TERM_TRIM2 PULLUP_P_GATE 0.14339f
C3389 TERM_N_R TRIM_P_2_R 0.10194f
C3390 PULLDOWN_P_R TERM_OR_P_PLS 0
C3391 HS_P_2 HS_N_2 0.09155f
C3392 FS_PB_GATE HS_N_8 0.30021f
C3393 FS_LOW_P LS_SLOW_B 0.04331f
C3394 FS_PB_BLEED_0 HS_N_5 0.0458f
C3395 DIV_ENABLE FS_N_OUT 0.1719f
C3396 TRIM_P_1_R TERM_LSA_GATE_P 0.0535f
C3397 PULLDOWN_P_R DIV_ENABLE 0.05263f
C3398 PULLUP_N_OUT HS_N_5 0.00515f
C3399 PULLDOWN_N_R HS_N_2 0.02404f
C3400 PULLDOWN_N_R PULLUP_P_BLEED_0 0.05924f
C3401 TERM_GATE_P_BLEED_0 HS_P_10 0.01262f
C3402 FS_PB_BLEED_0 HS_N_8 0.05643f
C3403 FS_N_GATE FS_N_BLEED_5 0.05106f
C3404 FS_PB_GATE FS_PB_BLEED_2 0.06215f
C3405 HS_N_2 PAD_N 1.19108f
C3406 PULLUP_N_OUT PULLUP_N_GATE 11.6582f
C3407 PULLUP_N_BLEED_4 PULLUP_N_BLEED_3 0.034f
C3408 PULLUP_N_OUT FS_N_BLEED_2 0.05095f
C3409 TERM_OR_N_S VDD 4.85556f
C3410 LS_SLOW_B DIV_ENABLE 0.04628f
C3411 HS_N_5 HS_P_3 0.03089f
C3412 PULLUP_N_OUT HS_N_8 0.05975f
C3413 TERM_VCM BYPASS_ENABLE 0.01778f
C3414 TRIM_P_0_R FS_N_OUT 0.05082f
C3415 LS_SLOW PULLUP_N_BLEED_4 0.00836f
C3416 TERM_TRIM1 FS_N_BLEED_4 0.12499f
C3417 TERM_P_R VDD 5.9415f
C3418 PULLDOWN_P_R TRIM_P_0_R 0.09116f
C3419 TERM_OR_N_S TRIM_N_1_R 0.03472f
C3420 HS_N_9 TERM_GATE_P_BLEED_0 0.06246f
C3421 HS_N_8 HS_P_3 0.02425f
C3422 FS_PB_CONTROL_LS TERM_TRIM2 0.06219f
C3423 TERM_N_R TERM_GATE_P 0.1177f
C3424 FS_PB_BLEED_2 PULLUP_N_OUT 0.22623f
C3425 HS_P_0 HS_P_10 2.18186f
C3426 LS_SLOW_B TRIM_P_0_R 0.06955f
C3427 TERM_GATE_N PULLDOWN_N_R 0.25579f
C3428 TRIM_N_1_R TERM_P_R 0.15915f
C3429 PULLUP_P PULLUP_P_BLEED_4 0.82704f
C3430 HS_N_0 HS_N_7 0.07113f
C3431 FS_LOW_N PULLUP_N_BLEED_2 0.08389f
C3432 HS_N_4 TRIM_N_0_R 0.03489f
C3433 DIV_LOW_P TERM_VCM 0.14093f
C3434 FS_LOW_P PULLUP_P_WELL 0.27192f
C3435 HS_N_9 HS_P_0 0.03775f
C3436 FS_NB_BLEED_3 FS_NB_GATE 0.09779f
C3437 PULLUP_N_GATE FS_HIGH_N 0.00262f
C3438 TERM_TRIM2 TERM_TRIM1 0.19666p
C3439 FS_N_WELL FS_NB_GATE 0.16026p
C3440 DIV_N DIV_LOW_N 0.04685f
C3441 FS_P_GATE VDD 25.9278f
C3442 DIV_N TERM_TRIM0 0.0314f
C3443 a_41005_132385# a_41005_132945# 0.0346f
C3444 TERM_OR_P_S VDD 10.4257f
C3445 HS_N_5 HS_N_13 0.10387f
C3446 PULLUP_P_WELL DIV_ENABLE 0.01343f
C3447 TRIM_P_1_R TERM_OR_P_B 0.05963f
C3448 HS_N_4 HS_N_10 0
C3449 FS_NB_GATE TERM_TRIM0 0.39698f
C3450 DIV_LOW_N HS_N_1 0.008f
C3451 HS_N_0 FS_PB_BLEED_5 0.03931f
C3452 TRIM_N_1_R FS_P_GATE 0.10569f
C3453 TERM_OR_N_S FS_LOW_N 0.48544f
C3454 TERM_TRIM0 HS_N_1 0.07686f
C3455 TERM_OR_P_S TRIM_N_1_R 0.04117f
C3456 TERM_ENABLE FS_LOW_P 0.07351f
C3457 PULLDOWN_P LS_SLOW 1.46196f
C3458 HS_P_7 HS_P 0.53266f
C3459 HS_P_7 VCM_LOW_OK 0.13109f
C3460 TERM_TRIM2 FS_P_BLEED_3 0.06152f
C3461 HS_N_8 HS_N_13 0.05624f
C3462 DIV_LOW_P TRIM_N_2_R 0.00564f
C3463 FS_LOW_N TERM_P_R 0.09501f
C3464 HS_N_4 HS_N_11 0
C3465 TERM_ENABLE TERM_OR_P_PLS 0.01194f
C3466 HS_P_6 TERM_P_R 0.15543f
C3467 LS_SLOW FS_P_WELL 7.8377f
C3468 DIV_N TERM_LSA_GATE_P 0.03859f
C3469 LS_SLOW HS_P_13 0.07773f
C3470 HS_P_5 HS_P_13 0.10387f
C3471 TERM_ENABLE DIV_ENABLE 0.10594f
C3472 BYPASS_ENABLE HS_N 0.01049f
C3473 HS_P FS_N_WELL 1.5591f
C3474 PULLUP_N_OUT PAD_P 0.17561f
C3475 TERM_P_R HS_N_3 0.09381f
C3476 DIV_P TERM_TRIM1 0.01945f
C3477 FS_HIGH_P PULLDOWN_N_R 0.12678f
C3478 FS_LOW_P HS_P_8 0.2119f
C3479 TERM_LSA_GATE_P HS_N_1 0.05893f
C3480 HS_N_5 TERM_GATE_N_BLEED_2 0
C3481 PAD_P HS_P_3 1.74939f
C3482 PULLUP_P_OUT FS_P_WELL 2.92072f
C3483 VCM_LOW_OK TERM_TRIM0 0.06532f
C3484 ATB_ESD_RAIL VSS 0.86326f
C3485 RX_N VSS 44.1498f
C3486 RX_P VSS 43.7529f
C3487 BYPASS_ENABLE VSS 68.5906f
C3488 HS_N VSS 66.6144f
C3489 HS_P VSS 45.7044f
C3490 PAD_N VSS 0.38645p
C3491 PAD_P VSS 0.38806p
C3492 FS_HIGH_P VSS 16.7805f
C3493 PULLDOWN_P VSS 11.9986f
C3494 TERM_ENABLE VSS 53.011f
C3495 FS_LOW_P VSS 44.224f
C3496 LS_SLOW VSS 32.2645f
C3497 DIV_ENABLE VSS 30.0487f
C3498 TERM_TRIM2 VSS 9.22743f
C3499 TERM_TRIM1 VSS 7.48244f
C3500 TERM_VCM VSS 0.20443p
C3501 TERM_TRIM0 VSS 9.70433f
C3502 HS_PBIAS VSS 57.433f
C3503 PULLUP_P VSS 23.2115f
C3504 FS_LOW_N VSS 9.67566f
C3505 FS_HIGH_N VSS 14.4891f
C3506 PULLUP_N VSS 2.00484f
C3507 PULLDOWN_N VSS 5.43945f
C3508 DIFF_ENABLE VSS 14.9632f
C3509 ESD_RAIL VSS 2978.471328f
C3510 VDD VSS 0.86658p
C3511 m2_42279_124800# VSS 7.46506f $ **FLOATING
C3512 a_42245_90628# VSS 0.24972p
C3513 a_44789_117064# VSS 8.91806f
C3514 a_43813_117064# VSS 5.17875f
C3515 a_41005_131545# VSS 98.15211f
C3516 a_53878_131545# VSS 0.07835f
C3517 a_41005_131825# VSS 0.07377f
C3518 a_53878_132105# VSS 0.07394f
C3519 a_41005_132385# VSS 0.07377f
C3520 a_53878_132665# VSS 0.07394f
C3521 TERM_OR_P_NS VSS 4.68639f
C3522 a_41005_132945# VSS 0.07377f
C3523 a_53878_133225# VSS 0.07394f
C3524 a_41005_133505# VSS 0.07377f
C3525 a_53878_133785# VSS 0.07394f
C3526 a_41005_134065# VSS 0.07377f
C3527 a_53878_134345# VSS 0.07838f
C3528 TERM_OR_P_PLS VSS 1.64228f
C3529 TERM_OR_P_B VSS 16.4334f
C3530 TERM_OR_P_S VSS 6.03217f
C3531 TERM_GATE_P_BLEED_2 VSS 3.6231f
C3532 TERM_GATE_P_BLEED_1 VSS 4.57072f
C3533 TERM_GATE_P_BLEED_0 VSS 3.52713f
C3534 TERM_LSA_GATE_P VSS 23.7113f
C3535 HS_P_0 VSS 10.9492f
C3536 DIV_LOW_P VSS 6.21578f
C3537 DIV_P VSS 18.6609f
C3538 TRIM_P_2_R VSS 16.036f
C3539 TRIM_P_1_R VSS 18.8687f
C3540 TRIM_P_0_R VSS 21.9599f
C3541 TERM_GATE_P VSS 27.05f
C3542 a_41852_148519# VSS 0.41778p
C3543 HS_P_7 VSS 6.80769f
C3544 HS_P_6 VSS 6.69007f
C3545 HS_P_5 VSS 6.98466f
C3546 HS_P_4 VSS 6.07886f
C3547 HS_P_3 VSS 7.25807f
C3548 HS_P_2 VSS 8.28644f
C3549 HS_P_1 VSS 7.3631f
C3550 HS_P_13 VSS 6.93821f
C3551 HS_P_12 VSS 6.91707f
C3552 HS_P_11 VSS 7.6045f
C3553 HS_P_10 VSS 6.63995f
C3554 HS_P_9 VSS 8.81395f
C3555 HS_P_8 VSS 7.70557f
C3556 FS_P_CONTROL_S VSS 7.20242f
C3557 FS_P_OUT VSS 51.4843f
C3558 FS_P_BLEED_3 VSS 3.59896f
C3559 FS_P_BLEED_2 VSS 3.46736f
C3560 FS_P_BLEED_1 VSS 3.53878f
C3561 FS_P_BLEED_0 VSS 4.25872f
C3562 FS_PB_CONTROL_LS VSS 7.27443f
C3563 FS_PB_CONTROL_S VSS 5.62605f
C3564 FS_P_GATE VSS 23.6521f
C3565 FS_P_BLEED_6 VSS 3.20674f
C3566 FS_P_BLEED_5 VSS 3.61125f
C3567 FS_P_BLEED_4 VSS 11.7746f
C3568 FS_PB_BLEED_4 VSS 3.61941f
C3569 FS_PB_BLEED_3 VSS 3.48799f
C3570 FS_PB_BLEED_2 VSS 3.69518f
C3571 FS_PB_BLEED_1 VSS 4.38037f
C3572 FS_PB_BLEED_0 VSS 3.47681f
C3573 FS_PB_GATE VSS 35.9173f
C3574 FS_PB_BLEED_6 VSS 3.74458f
C3575 FS_PB_BLEED_5 VSS 11.6376f
C3576 PULLUP_P_CONTROL_S VSS 3.81166f
C3577 PULLUP_P_OUT VSS 27.2385f
C3578 PULLUP_P_GATE VSS 16.0995f
C3579 PULLUP_P_BLEED_6 VSS 3.62129f
C3580 PULLUP_P_BLEED_5 VSS 3.48967f
C3581 PULLUP_P_BLEED_4 VSS 3.67452f
C3582 PULLUP_P_BLEED_3 VSS 4.38448f
C3583 PULLUP_P_BLEED_2 VSS 3.56334f
C3584 PULLUP_P_BLEED_1 VSS 3.74346f
C3585 PULLUP_P_BLEED_0 VSS 10.6023f
C3586 TERM_OR_N_S VSS 3.55049f
C3587 VCM_LOW_OK VSS 18.8064f
C3588 TERM_OR_N_NS VSS 4.76773f
C3589 PULLDOWN_P_R VSS 14.8644f
C3590 TERM_OR_N_PLS VSS 2.17987f
C3591 TERM_OR_N_B VSS 23.0515f
C3592 TERM_LSA_GATE_N VSS 11.9838f
C3593 TERM_GATE_N_BLEED_2 VSS 4.57674f
C3594 TERM_GATE_N_BLEED_1 VSS 3.56584f
C3595 TERM_GATE_N_BLEED_0 VSS 3.74717f
C3596 TERM_GATE_N VSS 31.3848f
C3597 HS_N_1 VSS 12.3436f
C3598 HS_N_0 VSS 13.128f
C3599 DIV_LOW_N VSS 5.94325f
C3600 DIV_N VSS 20.6661f
C3601 TRIM_N_2_R VSS 27.7926f
C3602 TRIM_N_1_R VSS 26.5007f
C3603 TRIM_N_0_R VSS 13.5472f
C3604 HS_N_8 VSS 10.6797f
C3605 HS_N_7 VSS 9.29132f
C3606 HS_N_6 VSS 11.0125f
C3607 HS_N_5 VSS 9.56943f
C3608 HS_N_4 VSS 8.66269f
C3609 HS_N_3 VSS 9.07896f
C3610 HS_N_2 VSS 11.0274f
C3611 HS_N_13 VSS 10.0576f
C3612 HS_N_12 VSS 11.9478f
C3613 HS_N_11 VSS 10.5049f
C3614 HS_N_10 VSS 10.2333f
C3615 HS_N_9 VSS 10.895f
C3616 FS_N_CONTROL_S VSS 6.27658f
C3617 FS_N_OUT VSS 0.10318p
C3618 FS_N_BLEED_4 VSS 3.63801f
C3619 FS_N_BLEED_3 VSS 3.48882f
C3620 FS_N_BLEED_2 VSS 3.60448f
C3621 FS_N_BLEED_1 VSS 4.72441f
C3622 FS_N_BLEED_0 VSS 3.47781f
C3623 FS_NB_CONTROL_LS VSS 7.0322f
C3624 LS_SLOW_B VSS 28.966f
C3625 FS_NB_CONTROL_S VSS 5.42631f
C3626 FS_N_GATE VSS 28.9887f
C3627 FS_N_BLEED_6 VSS 3.68505f
C3628 FS_N_BLEED_5 VSS 11.6255f
C3629 FS_NB_BLEED_5 VSS 3.638f
C3630 FS_NB_BLEED_4 VSS 3.56357f
C3631 FS_NB_BLEED_3 VSS 3.70011f
C3632 FS_NB_BLEED_2 VSS 4.2338f
C3633 FS_NB_BLEED_1 VSS 3.56517f
C3634 FS_NB_BLEED_0 VSS 3.91456f
C3635 FS_NB_GATE VSS 36.0468f
C3636 FS_NB_BLEED_6 VSS 9.25687f
C3637 PULLUP_N_BLEED_0 VSS 3.31331f
C3638 PULLUP_N_CONTROL_S VSS 3.7673f
C3639 PULLUP_N_OUT VSS 35.9644f
C3640 PULLDOWN_N_R VSS 43.1392f
C3641 PULLUP_N_GATE VSS 12.8817f
C3642 PULLUP_N_BLEED_6 VSS 3.46849f
C3643 PULLUP_N_BLEED_5 VSS 3.59915f
C3644 PULLUP_N_BLEED_4 VSS 4.20567f
C3645 PULLUP_N_BLEED_3 VSS 3.56325f
C3646 PULLUP_N_BLEED_2 VSS 3.91058f
C3647 PULLUP_N_BLEED_1 VSS 11.0082f
C3648 TERM_P_R VSS 0.11262p
C3649 TERM_N_R VSS 0.11724p
C3650 FS_P_WELL VSS 0.47241p
C3651 PULLUP_P_WELL VSS 0.10038p
C3652 FS_N_WELL VSS 0.47692p
C3653 PULLUP_N_WELL VSS 99.6082f
DWELL_ARRAY VSS ESD_RAIL diode_nw2ps_06v0 area=1138.9056p pj=941.44u
.ends

.lib /home/ubuntu/svalbard/scratch/transceiver-pad-pdk/ngspice/sm141064.ngspice diode_typical
.lib /home/ubuntu/svalbard/scratch/transceiver-pad-pdk/ngspice/sm141064.ngspice mimcap_typical
